* NGSPICE file created from single_cycle_cpu.ext - technology: sky130A

* Black-box entry subcircuit for sky130_fd_sc_hd__fill_2 abstract view
.subckt sky130_fd_sc_hd__fill_2 VGND VNB VPB VPWR
.ends

* Black-box entry subcircuit for sky130_fd_sc_hd__decap_3 abstract view
.subckt sky130_fd_sc_hd__decap_3 VGND VNB VPB VPWR
.ends

* Black-box entry subcircuit for sky130_fd_sc_hd__dfxtp_2 abstract view
.subckt sky130_fd_sc_hd__dfxtp_2 CLK D VGND VNB VPB VPWR Q
.ends

* Black-box entry subcircuit for sky130_fd_sc_hd__tapvpwrvgnd_1 abstract view
.subckt sky130_fd_sc_hd__tapvpwrvgnd_1 VGND VPWR
.ends

* Black-box entry subcircuit for sky130_fd_sc_hd__mux2_2 abstract view
.subckt sky130_fd_sc_hd__mux2_2 A0 A1 S VGND VNB VPB VPWR X
.ends

* Black-box entry subcircuit for sky130_fd_sc_hd__nor4_2 abstract view
.subckt sky130_fd_sc_hd__nor4_2 A B C D VGND VNB VPB VPWR Y
.ends

* Black-box entry subcircuit for sky130_fd_sc_hd__or2_2 abstract view
.subckt sky130_fd_sc_hd__or2_2 A B VGND VNB VPB VPWR X
.ends

* Black-box entry subcircuit for sky130_fd_sc_hd__dfrtp_2 abstract view
.subckt sky130_fd_sc_hd__dfrtp_2 CLK D RESET_B VGND VNB VPB VPWR Q
.ends

* Black-box entry subcircuit for sky130_fd_sc_hd__fill_1 abstract view
.subckt sky130_fd_sc_hd__fill_1 VGND VNB VPB VPWR
.ends

* Black-box entry subcircuit for sky130_fd_sc_hd__dlygate4sd3_1 abstract view
.subckt sky130_fd_sc_hd__dlygate4sd3_1 A VGND VNB VPB VPWR X
.ends

* Black-box entry subcircuit for sky130_fd_sc_hd__nor3_2 abstract view
.subckt sky130_fd_sc_hd__nor3_2 A B C VGND VNB VPB VPWR Y
.ends

* Black-box entry subcircuit for sky130_fd_sc_hd__a221o_2 abstract view
.subckt sky130_fd_sc_hd__a221o_2 A1 A2 B1 B2 C1 VGND VNB VPB VPWR X
.ends

* Black-box entry subcircuit for sky130_fd_sc_hd__inv_2 abstract view
.subckt sky130_fd_sc_hd__inv_2 A VGND VNB VPB VPWR Y
.ends

* Black-box entry subcircuit for sky130_fd_sc_hd__a22o_2 abstract view
.subckt sky130_fd_sc_hd__a22o_2 A1 A2 B1 B2 VGND VNB VPB VPWR X
.ends

* Black-box entry subcircuit for sky130_fd_sc_hd__clkdlybuf4s25_1 abstract view
.subckt sky130_fd_sc_hd__clkdlybuf4s25_1 A VGND VNB VPB VPWR X
.ends

* Black-box entry subcircuit for sky130_fd_sc_hd__a211o_2 abstract view
.subckt sky130_fd_sc_hd__a211o_2 A1 A2 B1 C1 VGND VNB VPB VPWR X
.ends

* Black-box entry subcircuit for sky130_fd_sc_hd__and3_4 abstract view
.subckt sky130_fd_sc_hd__and3_4 A B C VGND VNB VPB VPWR X
.ends

* Black-box entry subcircuit for sky130_fd_sc_hd__a31o_2 abstract view
.subckt sky130_fd_sc_hd__a31o_2 A1 A2 A3 B1 VGND VNB VPB VPWR X
.ends

* Black-box entry subcircuit for sky130_fd_sc_hd__or4_4 abstract view
.subckt sky130_fd_sc_hd__or4_4 A B C D VGND VNB VPB VPWR X
.ends

* Black-box entry subcircuit for sky130_fd_sc_hd__nor2_2 abstract view
.subckt sky130_fd_sc_hd__nor2_2 A B VGND VNB VPB VPWR Y
.ends

* Black-box entry subcircuit for sky130_fd_sc_hd__o31a_2 abstract view
.subckt sky130_fd_sc_hd__o31a_2 A1 A2 A3 B1 VGND VNB VPB VPWR X
.ends

* Black-box entry subcircuit for sky130_fd_sc_hd__conb_1 abstract view
.subckt sky130_fd_sc_hd__conb_1 VGND VNB VPB VPWR HI LO
.ends

* Black-box entry subcircuit for sky130_fd_sc_hd__or3b_4 abstract view
.subckt sky130_fd_sc_hd__or3b_4 A B C_N VGND VNB VPB VPWR X
.ends

* Black-box entry subcircuit for sky130_fd_sc_hd__and2_2 abstract view
.subckt sky130_fd_sc_hd__and2_2 A B VGND VNB VPB VPWR X
.ends

* Black-box entry subcircuit for sky130_fd_sc_hd__xnor2_2 abstract view
.subckt sky130_fd_sc_hd__xnor2_2 A B VGND VNB VPB VPWR Y
.ends

* Black-box entry subcircuit for sky130_fd_sc_hd__o21ai_2 abstract view
.subckt sky130_fd_sc_hd__o21ai_2 A1 A2 B1 VGND VNB VPB VPWR Y
.ends

* Black-box entry subcircuit for sky130_fd_sc_hd__nand2_2 abstract view
.subckt sky130_fd_sc_hd__nand2_2 A B VGND VNB VPB VPWR Y
.ends

* Black-box entry subcircuit for sky130_fd_sc_hd__and3_2 abstract view
.subckt sky130_fd_sc_hd__and3_2 A B C VGND VNB VPB VPWR X
.ends

* Black-box entry subcircuit for sky130_fd_sc_hd__and2b_2 abstract view
.subckt sky130_fd_sc_hd__and2b_2 A_N B VGND VNB VPB VPWR X
.ends

* Black-box entry subcircuit for sky130_fd_sc_hd__a21o_2 abstract view
.subckt sky130_fd_sc_hd__a21o_2 A1 A2 B1 VGND VNB VPB VPWR X
.ends

* Black-box entry subcircuit for sky130_fd_sc_hd__or3_2 abstract view
.subckt sky130_fd_sc_hd__or3_2 A B C VGND VNB VPB VPWR X
.ends

* Black-box entry subcircuit for sky130_fd_sc_hd__buf_2 abstract view
.subckt sky130_fd_sc_hd__buf_2 A VGND VNB VPB VPWR X
.ends

* Black-box entry subcircuit for sky130_fd_sc_hd__diode_2 abstract view
.subckt sky130_fd_sc_hd__diode_2 DIODE VGND VNB VPB VPWR
.ends

* Black-box entry subcircuit for sky130_fd_sc_hd__a31oi_4 abstract view
.subckt sky130_fd_sc_hd__a31oi_4 A1 A2 A3 B1 VGND VNB VPB VPWR Y
.ends

* Black-box entry subcircuit for sky130_fd_sc_hd__o21a_2 abstract view
.subckt sky130_fd_sc_hd__o21a_2 A1 A2 B1 VGND VNB VPB VPWR X
.ends

* Black-box entry subcircuit for sky130_fd_sc_hd__o32a_2 abstract view
.subckt sky130_fd_sc_hd__o32a_2 A1 A2 A3 B1 B2 VGND VNB VPB VPWR X
.ends

* Black-box entry subcircuit for sky130_fd_sc_hd__or3b_2 abstract view
.subckt sky130_fd_sc_hd__or3b_2 A B C_N VGND VNB VPB VPWR X
.ends

* Black-box entry subcircuit for sky130_fd_sc_hd__clkbuf_16 abstract view
.subckt sky130_fd_sc_hd__clkbuf_16 A VGND VNB VPB VPWR X
.ends

* Black-box entry subcircuit for sky130_fd_sc_hd__o211ai_2 abstract view
.subckt sky130_fd_sc_hd__o211ai_2 A1 A2 B1 C1 VGND VNB VPB VPWR Y
.ends

* Black-box entry subcircuit for sky130_fd_sc_hd__o22a_2 abstract view
.subckt sky130_fd_sc_hd__o22a_2 A1 A2 B1 B2 VGND VNB VPB VPWR X
.ends

* Black-box entry subcircuit for sky130_fd_sc_hd__o221a_2 abstract view
.subckt sky130_fd_sc_hd__o221a_2 A1 A2 B1 B2 C1 VGND VNB VPB VPWR X
.ends

* Black-box entry subcircuit for sky130_fd_sc_hd__o311a_4 abstract view
.subckt sky130_fd_sc_hd__o311a_4 A1 A2 A3 B1 C1 VGND VNB VPB VPWR X
.ends

* Black-box entry subcircuit for sky130_fd_sc_hd__a211oi_4 abstract view
.subckt sky130_fd_sc_hd__a211oi_4 A1 A2 B1 C1 VGND VNB VPB VPWR Y
.ends

* Black-box entry subcircuit for sky130_fd_sc_hd__xor2_2 abstract view
.subckt sky130_fd_sc_hd__xor2_2 A B VGND VNB VPB VPWR X
.ends

* Black-box entry subcircuit for sky130_fd_sc_hd__or4b_2 abstract view
.subckt sky130_fd_sc_hd__or4b_2 A B C D_N VGND VNB VPB VPWR X
.ends

* Black-box entry subcircuit for sky130_fd_sc_hd__o2bb2a_2 abstract view
.subckt sky130_fd_sc_hd__o2bb2a_2 A1_N A2_N B1 B2 VGND VNB VPB VPWR X
.ends

* Black-box entry subcircuit for sky130_fd_sc_hd__nand3_2 abstract view
.subckt sky130_fd_sc_hd__nand3_2 A B C VGND VNB VPB VPWR Y
.ends

* Black-box entry subcircuit for sky130_fd_sc_hd__o31ai_4 abstract view
.subckt sky130_fd_sc_hd__o31ai_4 A1 A2 A3 B1 VGND VNB VPB VPWR Y
.ends

* Black-box entry subcircuit for sky130_fd_sc_hd__o21ba_2 abstract view
.subckt sky130_fd_sc_hd__o21ba_2 A1 A2 B1_N VGND VNB VPB VPWR X
.ends

* Black-box entry subcircuit for sky130_fd_sc_hd__or2_4 abstract view
.subckt sky130_fd_sc_hd__or2_4 A B VGND VNB VPB VPWR X
.ends

* Black-box entry subcircuit for sky130_fd_sc_hd__a211oi_2 abstract view
.subckt sky130_fd_sc_hd__a211oi_2 A1 A2 B1 C1 VGND VNB VPB VPWR Y
.ends

* Black-box entry subcircuit for sky130_fd_sc_hd__a21bo_2 abstract view
.subckt sky130_fd_sc_hd__a21bo_2 A1 A2 B1_N VGND VNB VPB VPWR X
.ends

* Black-box entry subcircuit for sky130_fd_sc_hd__a31oi_2 abstract view
.subckt sky130_fd_sc_hd__a31oi_2 A1 A2 A3 B1 VGND VNB VPB VPWR Y
.ends

* Black-box entry subcircuit for sky130_fd_sc_hd__a21oi_2 abstract view
.subckt sky130_fd_sc_hd__a21oi_2 A1 A2 B1 VGND VNB VPB VPWR Y
.ends

* Black-box entry subcircuit for sky130_fd_sc_hd__o211a_2 abstract view
.subckt sky130_fd_sc_hd__o211a_2 A1 A2 B1 C1 VGND VNB VPB VPWR X
.ends

* Black-box entry subcircuit for sky130_fd_sc_hd__or2b_2 abstract view
.subckt sky130_fd_sc_hd__or2b_2 A B_N VGND VNB VPB VPWR X
.ends

* Black-box entry subcircuit for sky130_fd_sc_hd__a32o_2 abstract view
.subckt sky130_fd_sc_hd__a32o_2 A1 A2 A3 B1 B2 VGND VNB VPB VPWR X
.ends

* Black-box entry subcircuit for sky130_fd_sc_hd__a2bb2o_2 abstract view
.subckt sky130_fd_sc_hd__a2bb2o_2 A1_N A2_N B1 B2 VGND VNB VPB VPWR X
.ends

* Black-box entry subcircuit for sky130_fd_sc_hd__xor2_4 abstract view
.subckt sky130_fd_sc_hd__xor2_4 A B VGND VNB VPB VPWR X
.ends

* Black-box entry subcircuit for sky130_fd_sc_hd__a21boi_2 abstract view
.subckt sky130_fd_sc_hd__a21boi_2 A1 A2 B1_N VGND VNB VPB VPWR Y
.ends

* Black-box entry subcircuit for sky130_fd_sc_hd__and2_4 abstract view
.subckt sky130_fd_sc_hd__and2_4 A B VGND VNB VPB VPWR X
.ends

* Black-box entry subcircuit for sky130_fd_sc_hd__o2111a_2 abstract view
.subckt sky130_fd_sc_hd__o2111a_2 A1 A2 B1 C1 D1 VGND VNB VPB VPWR X
.ends

* Black-box entry subcircuit for sky130_fd_sc_hd__and4_4 abstract view
.subckt sky130_fd_sc_hd__and4_4 A B C D VGND VNB VPB VPWR X
.ends

* Black-box entry subcircuit for sky130_fd_sc_hd__o31ai_2 abstract view
.subckt sky130_fd_sc_hd__o31ai_2 A1 A2 A3 B1 VGND VNB VPB VPWR Y
.ends

* Black-box entry subcircuit for sky130_fd_sc_hd__buf_1 abstract view
.subckt sky130_fd_sc_hd__buf_1 A VGND VNB VPB VPWR X
.ends

* Black-box entry subcircuit for sky130_fd_sc_hd__o311a_2 abstract view
.subckt sky130_fd_sc_hd__o311a_2 A1 A2 A3 B1 C1 VGND VNB VPB VPWR X
.ends

* Black-box entry subcircuit for sky130_fd_sc_hd__clkinv_2 abstract view
.subckt sky130_fd_sc_hd__clkinv_2 A VGND VNB VPB VPWR Y
.ends

* Black-box entry subcircuit for sky130_fd_sc_hd__a31o_4 abstract view
.subckt sky130_fd_sc_hd__a31o_4 A1 A2 A3 B1 VGND VNB VPB VPWR X
.ends

* Black-box entry subcircuit for sky130_fd_sc_hd__clkbuf_8 abstract view
.subckt sky130_fd_sc_hd__clkbuf_8 A VGND VNB VPB VPWR X
.ends

* Black-box entry subcircuit for sky130_fd_sc_hd__inv_4 abstract view
.subckt sky130_fd_sc_hd__inv_4 A VGND VNB VPB VPWR Y
.ends

* Black-box entry subcircuit for sky130_fd_sc_hd__nor2_4 abstract view
.subckt sky130_fd_sc_hd__nor2_4 A B VGND VNB VPB VPWR Y
.ends

* Black-box entry subcircuit for sky130_fd_sc_hd__clkbuf_1 abstract view
.subckt sky130_fd_sc_hd__clkbuf_1 A VGND VNB VPB VPWR X
.ends

* Black-box entry subcircuit for sky130_fd_sc_hd__a221oi_2 abstract view
.subckt sky130_fd_sc_hd__a221oi_2 A1 A2 B1 B2 C1 VGND VNB VPB VPWR Y
.ends

* Black-box entry subcircuit for sky130_fd_sc_hd__and3b_2 abstract view
.subckt sky130_fd_sc_hd__and3b_2 A_N B C VGND VNB VPB VPWR X
.ends

* Black-box entry subcircuit for sky130_fd_sc_hd__nand3b_2 abstract view
.subckt sky130_fd_sc_hd__nand3b_2 A_N B C VGND VNB VPB VPWR Y
.ends

* Black-box entry subcircuit for sky130_fd_sc_hd__or3_4 abstract view
.subckt sky130_fd_sc_hd__or3_4 A B C VGND VNB VPB VPWR X
.ends

* Black-box entry subcircuit for sky130_fd_sc_hd__nor4b_2 abstract view
.subckt sky130_fd_sc_hd__nor4b_2 A B C D_N VGND VNB VPB VPWR Y
.ends

* Black-box entry subcircuit for sky130_fd_sc_hd__a21oi_4 abstract view
.subckt sky130_fd_sc_hd__a21oi_4 A1 A2 B1 VGND VNB VPB VPWR Y
.ends

* Black-box entry subcircuit for sky130_fd_sc_hd__o221ai_2 abstract view
.subckt sky130_fd_sc_hd__o221ai_2 A1 A2 B1 B2 C1 VGND VNB VPB VPWR Y
.ends

* Black-box entry subcircuit for sky130_fd_sc_hd__nand2b_4 abstract view
.subckt sky130_fd_sc_hd__nand2b_4 A_N B VGND VNB VPB VPWR Y
.ends

* Black-box entry subcircuit for sky130_fd_sc_hd__a2111o_2 abstract view
.subckt sky130_fd_sc_hd__a2111o_2 A1 A2 B1 C1 D1 VGND VNB VPB VPWR X
.ends

* Black-box entry subcircuit for sky130_fd_sc_hd__mux4_2 abstract view
.subckt sky130_fd_sc_hd__mux4_2 A0 A1 A2 A3 S0 S1 VGND VNB VPB VPWR X
.ends

* Black-box entry subcircuit for sky130_fd_sc_hd__dfstp_2 abstract view
.subckt sky130_fd_sc_hd__dfstp_2 CLK D SET_B VGND VNB VPB VPWR Q
.ends

* Black-box entry subcircuit for sky130_fd_sc_hd__nor2b_2 abstract view
.subckt sky130_fd_sc_hd__nor2b_2 A B_N VGND VNB VPB VPWR Y
.ends

* Black-box entry subcircuit for sky130_fd_sc_hd__or4_2 abstract view
.subckt sky130_fd_sc_hd__or4_2 A B C D VGND VNB VPB VPWR X
.ends

* Black-box entry subcircuit for sky130_fd_sc_hd__clkinvlp_4 abstract view
.subckt sky130_fd_sc_hd__clkinvlp_4 A VGND VNB VPB VPWR Y
.ends

* Black-box entry subcircuit for sky130_fd_sc_hd__buf_4 abstract view
.subckt sky130_fd_sc_hd__buf_4 A VGND VNB VPB VPWR X
.ends

* Black-box entry subcircuit for sky130_fd_sc_hd__clkbuf_2 abstract view
.subckt sky130_fd_sc_hd__clkbuf_2 A VGND VNB VPB VPWR X
.ends

* Black-box entry subcircuit for sky130_fd_sc_hd__and4_2 abstract view
.subckt sky130_fd_sc_hd__and4_2 A B C D VGND VNB VPB VPWR X
.ends

* Black-box entry subcircuit for sky130_fd_sc_hd__bufinv_16 abstract view
.subckt sky130_fd_sc_hd__bufinv_16 A VGND VNB VPB VPWR Y
.ends

* Black-box entry subcircuit for sky130_fd_sc_hd__a311oi_2 abstract view
.subckt sky130_fd_sc_hd__a311oi_2 A1 A2 A3 B1 C1 VGND VNB VPB VPWR Y
.ends

* Black-box entry subcircuit for sky130_fd_sc_hd__o21a_4 abstract view
.subckt sky130_fd_sc_hd__o21a_4 A1 A2 B1 VGND VNB VPB VPWR X
.ends

* Black-box entry subcircuit for sky130_fd_sc_hd__nor4_1 abstract view
.subckt sky130_fd_sc_hd__nor4_1 A B C D VGND VNB VPB VPWR Y
.ends

* Black-box entry subcircuit for sky130_fd_sc_hd__inv_6 abstract view
.subckt sky130_fd_sc_hd__inv_6 A VGND VNB VPB VPWR Y
.ends

* Black-box entry subcircuit for sky130_fd_sc_hd__a41o_2 abstract view
.subckt sky130_fd_sc_hd__a41o_2 A1 A2 A3 A4 B1 VGND VNB VPB VPWR X
.ends

* Black-box entry subcircuit for sky130_fd_sc_hd__nand4bb_2 abstract view
.subckt sky130_fd_sc_hd__nand4bb_2 A_N B_N C D VGND VNB VPB VPWR Y
.ends

* Black-box entry subcircuit for sky130_fd_sc_hd__o21bai_2 abstract view
.subckt sky130_fd_sc_hd__o21bai_2 A1 A2 B1_N VGND VNB VPB VPWR Y
.ends

* Black-box entry subcircuit for sky130_fd_sc_hd__nand2_4 abstract view
.subckt sky130_fd_sc_hd__nand2_4 A B VGND VNB VPB VPWR Y
.ends

* Black-box entry subcircuit for sky130_fd_sc_hd__mux2_4 abstract view
.subckt sky130_fd_sc_hd__mux2_4 A0 A1 S VGND VNB VPB VPWR X
.ends

* Black-box entry subcircuit for sky130_fd_sc_hd__o211ai_4 abstract view
.subckt sky130_fd_sc_hd__o211ai_4 A1 A2 B1 C1 VGND VNB VPB VPWR Y
.ends

* Black-box entry subcircuit for sky130_fd_sc_hd__and4bb_4 abstract view
.subckt sky130_fd_sc_hd__and4bb_4 A_N B_N C D VGND VNB VPB VPWR X
.ends

* Black-box entry subcircuit for sky130_fd_sc_hd__o31ai_1 abstract view
.subckt sky130_fd_sc_hd__o31ai_1 A1 A2 A3 B1 VGND VNB VPB VPWR Y
.ends

* Black-box entry subcircuit for sky130_fd_sc_hd__nand2b_2 abstract view
.subckt sky130_fd_sc_hd__nand2b_2 A_N B VGND VNB VPB VPWR Y
.ends

* Black-box entry subcircuit for sky130_fd_sc_hd__o211a_4 abstract view
.subckt sky130_fd_sc_hd__o211a_4 A1 A2 B1 C1 VGND VNB VPB VPWR X
.ends

* Black-box entry subcircuit for sky130_fd_sc_hd__or4b_4 abstract view
.subckt sky130_fd_sc_hd__or4b_4 A B C D_N VGND VNB VPB VPWR X
.ends

* Black-box entry subcircuit for sky130_fd_sc_hd__nor2_1 abstract view
.subckt sky130_fd_sc_hd__nor2_1 A B VGND VNB VPB VPWR Y
.ends

* Black-box entry subcircuit for sky130_fd_sc_hd__nor4bb_1 abstract view
.subckt sky130_fd_sc_hd__nor4bb_1 A B C_N D_N VGND VNB VPB VPWR Y
.ends

* Black-box entry subcircuit for sky130_fd_sc_hd__and4b_4 abstract view
.subckt sky130_fd_sc_hd__and4b_4 A_N B C D VGND VNB VPB VPWR X
.ends

* Black-box entry subcircuit for sky130_fd_sc_hd__nor3b_2 abstract view
.subckt sky130_fd_sc_hd__nor3b_2 A B C_N VGND VNB VPB VPWR Y
.ends

* Black-box entry subcircuit for sky130_fd_sc_hd__a22oi_2 abstract view
.subckt sky130_fd_sc_hd__a22oi_2 A1 A2 B1 B2 VGND VNB VPB VPWR Y
.ends

* Black-box entry subcircuit for sky130_fd_sc_hd__a311o_2 abstract view
.subckt sky130_fd_sc_hd__a311o_2 A1 A2 A3 B1 C1 VGND VNB VPB VPWR X
.ends

* Black-box entry subcircuit for sky130_fd_sc_hd__nand4b_4 abstract view
.subckt sky130_fd_sc_hd__nand4b_4 A_N B C D VGND VNB VPB VPWR Y
.ends

* Black-box entry subcircuit for sky130_fd_sc_hd__a2bb2o_4 abstract view
.subckt sky130_fd_sc_hd__a2bb2o_4 A1_N A2_N B1 B2 VGND VNB VPB VPWR X
.ends

.subckt single_cycle_cpu VGND VPWR alu_result_out[0] alu_result_out[10] alu_result_out[11]
+ alu_result_out[12] alu_result_out[13] alu_result_out[14] alu_result_out[15] alu_result_out[16]
+ alu_result_out[17] alu_result_out[18] alu_result_out[19] alu_result_out[1] alu_result_out[20]
+ alu_result_out[21] alu_result_out[22] alu_result_out[23] alu_result_out[24] alu_result_out[25]
+ alu_result_out[26] alu_result_out[27] alu_result_out[28] alu_result_out[29] alu_result_out[2]
+ alu_result_out[30] alu_result_out[31] alu_result_out[3] alu_result_out[4] alu_result_out[5]
+ alu_result_out[6] alu_result_out[7] alu_result_out[8] alu_result_out[9] clk instruction_out[0]
+ instruction_out[10] instruction_out[11] instruction_out[12] instruction_out[13]
+ instruction_out[14] instruction_out[15] instruction_out[16] instruction_out[17]
+ instruction_out[18] instruction_out[19] instruction_out[1] instruction_out[20] instruction_out[21]
+ instruction_out[22] instruction_out[23] instruction_out[24] instruction_out[25]
+ instruction_out[26] instruction_out[27] instruction_out[28] instruction_out[29]
+ instruction_out[2] instruction_out[30] instruction_out[31] instruction_out[3] instruction_out[4]
+ instruction_out[5] instruction_out[6] instruction_out[7] instruction_out[8] instruction_out[9]
+ pc_out[0] pc_out[10] pc_out[11] pc_out[12] pc_out[13] pc_out[14] pc_out[15] pc_out[16]
+ pc_out[17] pc_out[18] pc_out[19] pc_out[1] pc_out[20] pc_out[21] pc_out[22] pc_out[23]
+ pc_out[24] pc_out[25] pc_out[26] pc_out[27] pc_out[28] pc_out[29] pc_out[2] pc_out[30]
+ pc_out[31] pc_out[3] pc_out[4] pc_out[5] pc_out[6] pc_out[7] pc_out[8] pc_out[9]
+ reset
XFILLER_100_138 VGND VGND VPWR VPWR sky130_fd_sc_hd__fill_2
XFILLER_100_149 VGND VGND VPWR VPWR sky130_fd_sc_hd__decap_3
XFILLER_39_233 VGND VGND VPWR VPWR sky130_fd_sc_hd__decap_3
XFILLER_67_564 VGND VGND VPWR VPWR sky130_fd_sc_hd__decap_3
XFILLER_94_361 VGND VGND VPWR VPWR sky130_fd_sc_hd__decap_3
XFILLER_67_597 VGND VGND VPWR VPWR sky130_fd_sc_hd__decap_3
XFILLER_82_545 VGND VGND VPWR VPWR sky130_fd_sc_hd__decap_3
XFILLER_94_372 VGND VGND VPWR VPWR sky130_fd_sc_hd__decap_3
XFILLER_82_578 VGND VGND VPWR VPWR sky130_fd_sc_hd__decap_3
X_6914_ _6954_/CLK _6914_/D VGND VGND VPWR VPWR _6914_/Q sky130_fd_sc_hd__dfxtp_2
XFILLER_23_612 VGND VGND VPWR VPWR sky130_fd_sc_hd__decap_3
XFILLER_23_623 VGND VGND VPWR VPWR sky130_fd_sc_hd__decap_3
XFILLER_35_461 VGND VGND VPWR VPWR sky130_fd_sc_hd__decap_3
XFILLER_35_483 VGND VGND VPWR VPWR sky130_fd_sc_hd__decap_3
XFILLER_82_589 VGND VGND VPWR VPWR sky130_fd_sc_hd__decap_3
XFILLER_23_656 VGND VGND VPWR VPWR sky130_fd_sc_hd__decap_3
X_6845_ clkload7/A _6845_/D VGND VGND VPWR VPWR _6845_/Q sky130_fd_sc_hd__dfxtp_2
XTAP_TAPCELL_ROW_81_1226 VGND VPWR sky130_fd_sc_hd__tapvpwrvgnd_1
XFILLER_10_306 VGND VGND VPWR VPWR sky130_fd_sc_hd__fill_2
X_6776_ _6959_/CLK _6776_/D VGND VGND VPWR VPWR _6776_/Q sky130_fd_sc_hd__dfxtp_2
XTAP_TAPCELL_ROW_61_982 VGND VPWR sky130_fd_sc_hd__tapvpwrvgnd_1
XTAP_TAPCELL_ROW_33_651 VGND VPWR sky130_fd_sc_hd__tapvpwrvgnd_1
X_5727_ _7369_/Q hold916/X _5735_/S VGND VGND VPWR VPWR _6713_/D sky130_fd_sc_hd__mux2_2
XFILLER_108_249 VGND VGND VPWR VPWR sky130_fd_sc_hd__decap_3
X_5658_ _5658_/A _5658_/B _5658_/C _5658_/D VGND VGND VPWR VPWR _5661_/C sky130_fd_sc_hd__nor4_2
XPHY_EDGE_ROW_107_Left_224 VGND VGND VPWR VPWR sky130_fd_sc_hd__decap_3
X_5589_ _5589_/A _5595_/B VGND VGND VPWR VPWR _7033_/D sky130_fd_sc_hd__or2_2
XTAP_TAPCELL_ROW_79_1199 VGND VPWR sky130_fd_sc_hd__tapvpwrvgnd_1
XFILLER_2_516 VGND VGND VPWR VPWR sky130_fd_sc_hd__decap_3
XFILLER_89_100 VGND VGND VPWR VPWR sky130_fd_sc_hd__decap_3
XFILLER_89_122 VGND VGND VPWR VPWR sky130_fd_sc_hd__decap_3
X_7328_ _7328_/CLK _7328_/D _6608_/Y VGND VGND VPWR VPWR _7328_/Q sky130_fd_sc_hd__dfrtp_2
XFILLER_77_37 VGND VGND VPWR VPWR sky130_fd_sc_hd__fill_1
X_7259_ _7353_/CLK _7259_/D _6539_/Y VGND VGND VPWR VPWR _7259_/Q sky130_fd_sc_hd__dfrtp_2
XTAP_TAPCELL_ROW_92_1355 VGND VPWR sky130_fd_sc_hd__tapvpwrvgnd_1
XFILLER_104_466 VGND VGND VPWR VPWR sky130_fd_sc_hd__decap_3
XFILLER_104_477 VGND VGND VPWR VPWR sky130_fd_sc_hd__decap_3
XTAP_TAPCELL_ROW_5_310 VGND VPWR sky130_fd_sc_hd__tapvpwrvgnd_1
XFILLER_100_672 VGND VGND VPWR VPWR sky130_fd_sc_hd__decap_3
XFILLER_18_417 VGND VGND VPWR VPWR sky130_fd_sc_hd__decap_3
XFILLER_58_586 VGND VGND VPWR VPWR sky130_fd_sc_hd__fill_2
XFILLER_92_309 VGND VGND VPWR VPWR sky130_fd_sc_hd__decap_3
Xhold1040 _7265_/Q VGND VGND VPWR VPWR _4946_/A0 sky130_fd_sc_hd__dlygate4sd3_1
Xhold1051 _7242_/Q VGND VGND VPWR VPWR _5171_/A sky130_fd_sc_hd__dlygate4sd3_1
XFILLER_45_214 VGND VGND VPWR VPWR sky130_fd_sc_hd__decap_3
XFILLER_45_225 VGND VGND VPWR VPWR sky130_fd_sc_hd__decap_3
Xhold1062 _7284_/Q VGND VGND VPWR VPWR _4593_/A sky130_fd_sc_hd__dlygate4sd3_1
Xhold1073 _7288_/Q VGND VGND VPWR VPWR _4585_/A sky130_fd_sc_hd__dlygate4sd3_1
Xhold1084 _7234_/Q VGND VGND VPWR VPWR _5188_/A sky130_fd_sc_hd__dlygate4sd3_1
XPHY_EDGE_ROW_116_Left_233 VGND VGND VPWR VPWR sky130_fd_sc_hd__decap_3
XFILLER_73_556 VGND VGND VPWR VPWR sky130_fd_sc_hd__decap_3
XFILLER_73_567 VGND VGND VPWR VPWR sky130_fd_sc_hd__decap_3
Xhold1095 _7280_/Q VGND VGND VPWR VPWR _4601_/A0 sky130_fd_sc_hd__dlygate4sd3_1
XFILLER_14_601 VGND VGND VPWR VPWR sky130_fd_sc_hd__decap_3
XFILLER_60_206 VGND VGND VPWR VPWR sky130_fd_sc_hd__decap_3
XFILLER_60_217 VGND VGND VPWR VPWR sky130_fd_sc_hd__fill_1
XFILLER_14_634 VGND VGND VPWR VPWR sky130_fd_sc_hd__decap_3
XFILLER_14_645 VGND VGND VPWR VPWR sky130_fd_sc_hd__decap_3
XFILLER_26_96 VGND VGND VPWR VPWR sky130_fd_sc_hd__decap_3
XFILLER_60_239 VGND VGND VPWR VPWR sky130_fd_sc_hd__decap_3
XFILLER_14_678 VGND VGND VPWR VPWR sky130_fd_sc_hd__decap_3
XFILLER_41_464 VGND VGND VPWR VPWR sky130_fd_sc_hd__decap_3
XFILLER_42_62 VGND VGND VPWR VPWR sky130_fd_sc_hd__fill_1
XTAP_TAPCELL_ROW_101_1462 VGND VPWR sky130_fd_sc_hd__tapvpwrvgnd_1
XFILLER_9_148 VGND VGND VPWR VPWR sky130_fd_sc_hd__fill_1
XFILLER_5_310 VGND VGND VPWR VPWR sky130_fd_sc_hd__fill_2
XTAP_TAPCELL_ROW_11_389 VGND VPWR sky130_fd_sc_hd__tapvpwrvgnd_1
XTAP_TAPCELL_ROW_11_378 VGND VPWR sky130_fd_sc_hd__tapvpwrvgnd_1
XFILLER_54_9 VGND VGND VPWR VPWR sky130_fd_sc_hd__fill_2
XFILLER_5_387 VGND VGND VPWR VPWR sky130_fd_sc_hd__decap_3
XFILLER_3_12 VGND VGND VPWR VPWR sky130_fd_sc_hd__decap_3
XFILLER_96_604 VGND VGND VPWR VPWR sky130_fd_sc_hd__decap_3
XFILLER_110_403 VGND VGND VPWR VPWR sky130_fd_sc_hd__decap_3
XFILLER_110_414 VGND VGND VPWR VPWR sky130_fd_sc_hd__decap_3
XFILLER_96_637 VGND VGND VPWR VPWR sky130_fd_sc_hd__decap_3
XFILLER_110_436 VGND VGND VPWR VPWR sky130_fd_sc_hd__decap_3
XFILLER_96_648 VGND VGND VPWR VPWR sky130_fd_sc_hd__decap_3
XTAP_TAPCELL_ROW_112_1591 VGND VPWR sky130_fd_sc_hd__tapvpwrvgnd_1
XFILLER_110_469 VGND VGND VPWR VPWR sky130_fd_sc_hd__decap_3
XFILLER_49_564 VGND VGND VPWR VPWR sky130_fd_sc_hd__decap_3
XFILLER_95_169 VGND VGND VPWR VPWR sky130_fd_sc_hd__decap_3
XFILLER_36_203 VGND VGND VPWR VPWR sky130_fd_sc_hd__decap_3
XFILLER_49_597 VGND VGND VPWR VPWR sky130_fd_sc_hd__decap_3
XFILLER_64_523 VGND VGND VPWR VPWR sky130_fd_sc_hd__fill_2
XFILLER_91_320 VGND VGND VPWR VPWR sky130_fd_sc_hd__fill_1
XFILLER_36_236 VGND VGND VPWR VPWR sky130_fd_sc_hd__decap_3
XFILLER_64_545 VGND VGND VPWR VPWR sky130_fd_sc_hd__decap_3
XFILLER_64_578 VGND VGND VPWR VPWR sky130_fd_sc_hd__decap_3
XFILLER_91_331 VGND VGND VPWR VPWR sky130_fd_sc_hd__decap_3
XFILLER_91_353 VGND VGND VPWR VPWR sky130_fd_sc_hd__decap_3
XFILLER_51_217 VGND VGND VPWR VPWR sky130_fd_sc_hd__decap_3
XFILLER_51_228 VGND VGND VPWR VPWR sky130_fd_sc_hd__fill_2
XFILLER_64_589 VGND VGND VPWR VPWR sky130_fd_sc_hd__decap_3
X_4960_ _4960_/A _4960_/B _4960_/C VGND VGND VPWR VPWR _4961_/C sky130_fd_sc_hd__nor3_2
XTAP_TAPCELL_ROW_19_478 VGND VPWR sky130_fd_sc_hd__tapvpwrvgnd_1
XFILLER_32_442 VGND VGND VPWR VPWR sky130_fd_sc_hd__decap_3
XFILLER_51_239 VGND VGND VPWR VPWR sky130_fd_sc_hd__decap_3
XFILLER_83_91 VGND VGND VPWR VPWR sky130_fd_sc_hd__decap_3
X_4891_ _4970_/A1 _4126_/A _4889_/Y _4811_/C _4890_/Y VGND VGND VPWR VPWR _4891_/X
+ sky130_fd_sc_hd__a221o_2
X_3911_ _6690_/Q _5660_/B _3922_/B1 _6868_/Q _3910_/X VGND VGND VPWR VPWR _3911_/X
+ sky130_fd_sc_hd__a221o_2
XFILLER_20_604 VGND VGND VPWR VPWR sky130_fd_sc_hd__decap_3
X_6630_ _6630_/A VGND VGND VPWR VPWR _6630_/Y sky130_fd_sc_hd__inv_2
X_3842_ _6925_/Q _3886_/A2 _3886_/B1 _6789_/Q VGND VGND VPWR VPWR _3842_/X sky130_fd_sc_hd__a22o_2
XFILLER_20_637 VGND VGND VPWR VPWR sky130_fd_sc_hd__decap_3
XFILLER_20_648 VGND VGND VPWR VPWR sky130_fd_sc_hd__decap_3
X_6561_ _6635_/A VGND VGND VPWR VPWR _6561_/Y sky130_fd_sc_hd__inv_2
XTAP_TAPCELL_ROW_30_610 VGND VPWR sky130_fd_sc_hd__tapvpwrvgnd_1
X_3773_ _6775_/Q _3888_/A2 _3889_/A2 _6763_/Q VGND VGND VPWR VPWR _3773_/X sky130_fd_sc_hd__a22o_2
XFILLER_9_671 VGND VGND VPWR VPWR sky130_fd_sc_hd__fill_1
X_6492_ _6557_/A VGND VGND VPWR VPWR _6492_/Y sky130_fd_sc_hd__inv_2
XFILLER_9_682 VGND VGND VPWR VPWR sky130_fd_sc_hd__decap_3
X_7113_ _7307_/CLK _7113_/D _6393_/Y VGND VGND VPWR VPWR _7113_/Q sky130_fd_sc_hd__dfrtp_2
Xoutput478 _5652_/Y VGND VGND VPWR VPWR alu_result_out[27] sky130_fd_sc_hd__clkdlybuf4s25_1
Xoutput467 _5662_/C VGND VGND VPWR VPWR alu_result_out[17] sky130_fd_sc_hd__clkdlybuf4s25_1
X_4325_ _7354_/Q _4312_/B _4323_/X _4324_/X VGND VGND VPWR VPWR _4325_/X sky130_fd_sc_hd__a211o_2
XFILLER_113_263 VGND VGND VPWR VPWR sky130_fd_sc_hd__decap_3
XFILLER_87_615 VGND VGND VPWR VPWR sky130_fd_sc_hd__fill_1
XFILLER_87_626 VGND VGND VPWR VPWR sky130_fd_sc_hd__decap_3
Xoutput489 _5651_/Y VGND VGND VPWR VPWR alu_result_out[8] sky130_fd_sc_hd__clkdlybuf4s25_1
XFILLER_99_486 VGND VGND VPWR VPWR sky130_fd_sc_hd__decap_3
XFILLER_87_659 VGND VGND VPWR VPWR sky130_fd_sc_hd__decap_3
X_7044_ _7362_/CLK _7044_/D _6324_/Y VGND VGND VPWR VPWR _7044_/Q sky130_fd_sc_hd__dfrtp_2
X_4256_ _4626_/B _4626_/C _4256_/C VGND VGND VPWR VPWR _4988_/A sky130_fd_sc_hd__and3_4
XFILLER_101_469 VGND VGND VPWR VPWR sky130_fd_sc_hd__fill_1
XFILLER_74_309 VGND VGND VPWR VPWR sky130_fd_sc_hd__decap_3
X_4187_ _7327_/Q _3964_/S _4505_/S _7295_/Q VGND VGND VPWR VPWR _4187_/X sky130_fd_sc_hd__a22o_2
XFILLER_103_24 VGND VGND VPWR VPWR sky130_fd_sc_hd__decap_3
XTAP_TAPCELL_ROW_38_710 VGND VPWR sky130_fd_sc_hd__tapvpwrvgnd_1
XFILLER_55_567 VGND VGND VPWR VPWR sky130_fd_sc_hd__decap_3
XFILLER_82_342 VGND VGND VPWR VPWR sky130_fd_sc_hd__fill_1
XFILLER_103_68 VGND VGND VPWR VPWR sky130_fd_sc_hd__fill_1
XFILLER_82_375 VGND VGND VPWR VPWR sky130_fd_sc_hd__decap_3
XFILLER_11_615 VGND VGND VPWR VPWR sky130_fd_sc_hd__fill_1
X_6828_ _6974_/CLK _6828_/D VGND VGND VPWR VPWR _6828_/Q sky130_fd_sc_hd__dfxtp_2
XFILLER_10_125 VGND VGND VPWR VPWR sky130_fd_sc_hd__decap_3
XFILLER_11_626 VGND VGND VPWR VPWR sky130_fd_sc_hd__decap_3
XFILLER_50_283 VGND VGND VPWR VPWR sky130_fd_sc_hd__decap_3
XFILLER_50_294 VGND VGND VPWR VPWR sky130_fd_sc_hd__decap_3
XFILLER_109_503 VGND VGND VPWR VPWR sky130_fd_sc_hd__fill_1
XFILLER_109_514 VGND VGND VPWR VPWR sky130_fd_sc_hd__decap_3
XFILLER_11_659 VGND VGND VPWR VPWR sky130_fd_sc_hd__decap_3
X_6759_ clkload8/A _6759_/D VGND VGND VPWR VPWR _6759_/Q sky130_fd_sc_hd__dfxtp_2
XFILLER_109_547 VGND VGND VPWR VPWR sky130_fd_sc_hd__decap_3
XFILLER_12_43 VGND VGND VPWR VPWR sky130_fd_sc_hd__fill_1
XFILLER_78_604 VGND VGND VPWR VPWR sky130_fd_sc_hd__decap_3
XFILLER_78_637 VGND VGND VPWR VPWR sky130_fd_sc_hd__decap_3
XFILLER_77_147 VGND VGND VPWR VPWR sky130_fd_sc_hd__decap_3
XFILLER_78_648 VGND VGND VPWR VPWR sky130_fd_sc_hd__decap_3
XFILLER_65_309 VGND VGND VPWR VPWR sky130_fd_sc_hd__fill_1
XFILLER_93_629 VGND VGND VPWR VPWR sky130_fd_sc_hd__decap_3
XFILLER_100_480 VGND VGND VPWR VPWR sky130_fd_sc_hd__decap_3
XFILLER_86_681 VGND VGND VPWR VPWR sky130_fd_sc_hd__decap_3
XFILLER_92_139 VGND VGND VPWR VPWR sky130_fd_sc_hd__fill_1
XFILLER_46_567 VGND VGND VPWR VPWR sky130_fd_sc_hd__decap_3
XFILLER_85_191 VGND VGND VPWR VPWR sky130_fd_sc_hd__decap_3
XFILLER_46_589 VGND VGND VPWR VPWR sky130_fd_sc_hd__decap_3
XFILLER_73_364 VGND VGND VPWR VPWR sky130_fd_sc_hd__decap_3
XFILLER_33_228 VGND VGND VPWR VPWR sky130_fd_sc_hd__decap_3
XTAP_TAPCELL_ROW_16_448 VGND VPWR sky130_fd_sc_hd__tapvpwrvgnd_1
XTAP_TAPCELL_ROW_44_779 VGND VPWR sky130_fd_sc_hd__tapvpwrvgnd_1
XFILLER_14_475 VGND VGND VPWR VPWR sky130_fd_sc_hd__fill_1
XFILLER_41_261 VGND VGND VPWR VPWR sky130_fd_sc_hd__decap_3
XFILLER_10_681 VGND VGND VPWR VPWR sky130_fd_sc_hd__decap_3
XFILLER_6_663 VGND VGND VPWR VPWR sky130_fd_sc_hd__decap_3
XFILLER_115_517 VGND VGND VPWR VPWR sky130_fd_sc_hd__decap_3
XTAP_TAPCELL_ROW_114_1620 VGND VPWR sky130_fd_sc_hd__tapvpwrvgnd_1
XFILLER_5_184 VGND VGND VPWR VPWR sky130_fd_sc_hd__decap_3
XFILLER_69_615 VGND VGND VPWR VPWR sky130_fd_sc_hd__fill_1
XFILLER_69_626 VGND VGND VPWR VPWR sky130_fd_sc_hd__decap_3
XFILLER_69_659 VGND VGND VPWR VPWR sky130_fd_sc_hd__decap_3
XFILLER_78_91 VGND VGND VPWR VPWR sky130_fd_sc_hd__decap_3
X_5090_ _5146_/B1 _5083_/X _5085_/X _5089_/Y VGND VGND VPWR VPWR _5658_/C sky130_fd_sc_hd__a31o_2
X_4110_ _4376_/A _4141_/A _4141_/B _4142_/C VGND VGND VPWR VPWR _4111_/B sky130_fd_sc_hd__or4_4
XFILLER_56_309 VGND VGND VPWR VPWR sky130_fd_sc_hd__decap_3
XFILLER_84_607 VGND VGND VPWR VPWR sky130_fd_sc_hd__decap_3
XFILLER_96_467 VGND VGND VPWR VPWR sky130_fd_sc_hd__fill_1
X_4041_ _7245_/Q _4430_/A2 _4428_/B1 _7149_/Q VGND VGND VPWR VPWR _4041_/X sky130_fd_sc_hd__a22o_2
XFILLER_37_556 VGND VGND VPWR VPWR sky130_fd_sc_hd__decap_3
XFILLER_37_567 VGND VGND VPWR VPWR sky130_fd_sc_hd__decap_3
XFILLER_92_640 VGND VGND VPWR VPWR sky130_fd_sc_hd__decap_3
XFILLER_92_651 VGND VGND VPWR VPWR sky130_fd_sc_hd__decap_3
XFILLER_91_172 VGND VGND VPWR VPWR sky130_fd_sc_hd__fill_1
XFILLER_92_684 VGND VGND VPWR VPWR sky130_fd_sc_hd__decap_3
XFILLER_17_291 VGND VGND VPWR VPWR sky130_fd_sc_hd__decap_3
XFILLER_24_228 VGND VGND VPWR VPWR sky130_fd_sc_hd__fill_2
X_4943_ _4943_/A _4943_/B VGND VGND VPWR VPWR _4944_/C sky130_fd_sc_hd__nor2_2
XTAP_TAPCELL_ROW_65_1029 VGND VPWR sky130_fd_sc_hd__tapvpwrvgnd_1
XFILLER_32_272 VGND VGND VPWR VPWR sky130_fd_sc_hd__decap_3
XFILLER_60_570 VGND VGND VPWR VPWR sky130_fd_sc_hd__decap_3
XFILLER_60_592 VGND VGND VPWR VPWR sky130_fd_sc_hd__decap_3
X_6613_ _6613_/A VGND VGND VPWR VPWR _6613_/Y sky130_fd_sc_hd__inv_2
X_4874_ _4814_/A _4849_/Y _4872_/X _4873_/X VGND VGND VPWR VPWR _4874_/X sky130_fd_sc_hd__o31a_2
XFILLER_20_434 VGND VGND VPWR VPWR sky130_fd_sc_hd__decap_3
X_3825_ _6749_/Q _3918_/A2 _3903_/A2 _6737_/Q VGND VGND VPWR VPWR _3825_/X sky130_fd_sc_hd__a22o_2
X_6544_ _6637_/A VGND VGND VPWR VPWR _6544_/Y sky130_fd_sc_hd__inv_2
X_3756_ _6798_/Q _3918_/B1 _3917_/A2 _6708_/Q _3755_/X VGND VGND VPWR VPWR _3756_/X
+ sky130_fd_sc_hd__a221o_2
X_6475_ _6640_/A VGND VGND VPWR VPWR _6475_/Y sky130_fd_sc_hd__inv_2
XFILLER_106_528 VGND VGND VPWR VPWR sky130_fd_sc_hd__decap_3
XFILLER_106_539 VGND VGND VPWR VPWR sky130_fd_sc_hd__decap_3
XTAP_TAPCELL_ROW_76_1158 VGND VPWR sky130_fd_sc_hd__tapvpwrvgnd_1
XTAP_TAPCELL_ROW_76_1169 VGND VPWR sky130_fd_sc_hd__tapvpwrvgnd_1
XFILLER_114_572 VGND VGND VPWR VPWR sky130_fd_sc_hd__decap_3
XFILLER_59_103 VGND VGND VPWR VPWR sky130_fd_sc_hd__decap_3
XFILLER_99_261 VGND VGND VPWR VPWR sky130_fd_sc_hd__decap_3
XFILLER_99_250 VGND VGND VPWR VPWR sky130_fd_sc_hd__decap_3
XFILLER_87_434 VGND VGND VPWR VPWR sky130_fd_sc_hd__fill_2
X_5288_ hold991/X _3993_/X _5292_/S VGND VGND VPWR VPWR _7185_/D sky130_fd_sc_hd__mux2_2
X_4308_ _7192_/Q _3975_/S _4338_/B1 _7384_/Q VGND VGND VPWR VPWR _4308_/X sky130_fd_sc_hd__a22o_2
XFILLER_101_233 VGND VGND VPWR VPWR sky130_fd_sc_hd__decap_3
XFILLER_114_12 VGND VGND VPWR VPWR sky130_fd_sc_hd__decap_3
XFILLER_75_629 VGND VGND VPWR VPWR sky130_fd_sc_hd__decap_3
X_7027_ _7372_/CLK _7027_/D _6307_/Y VGND VGND VPWR VPWR _7027_/Q sky130_fd_sc_hd__dfrtp_2
X_4239_ _4628_/A _4629_/B VGND VGND VPWR VPWR _5018_/B sky130_fd_sc_hd__nor2_2
XFILLER_114_56 VGND VGND VPWR VPWR sky130_fd_sc_hd__decap_3
XFILLER_28_512 VGND VGND VPWR VPWR sky130_fd_sc_hd__decap_3
XFILLER_68_681 VGND VGND VPWR VPWR sky130_fd_sc_hd__decap_3
XFILLER_74_106 VGND VGND VPWR VPWR sky130_fd_sc_hd__decap_3
XFILLER_74_139 VGND VGND VPWR VPWR sky130_fd_sc_hd__fill_1
XFILLER_28_545 VGND VGND VPWR VPWR sky130_fd_sc_hd__decap_3
XFILLER_55_331 VGND VGND VPWR VPWR sky130_fd_sc_hd__decap_3
XFILLER_67_180 VGND VGND VPWR VPWR sky130_fd_sc_hd__fill_1
XFILLER_15_206 VGND VGND VPWR VPWR sky130_fd_sc_hd__decap_3
XFILLER_28_578 VGND VGND VPWR VPWR sky130_fd_sc_hd__decap_3
XFILLER_28_589 VGND VGND VPWR VPWR sky130_fd_sc_hd__decap_3
XFILLER_55_386 VGND VGND VPWR VPWR sky130_fd_sc_hd__decap_3
XFILLER_70_312 VGND VGND VPWR VPWR sky130_fd_sc_hd__decap_3
XFILLER_82_150 VGND VGND VPWR VPWR sky130_fd_sc_hd__fill_2
XFILLER_82_161 VGND VGND VPWR VPWR sky130_fd_sc_hd__decap_3
XFILLER_83_662 VGND VGND VPWR VPWR sky130_fd_sc_hd__decap_3
XFILLER_83_673 VGND VGND VPWR VPWR sky130_fd_sc_hd__decap_3
XFILLER_15_228 VGND VGND VPWR VPWR sky130_fd_sc_hd__decap_3
XTAP_TAPCELL_ROW_87_1298 VGND VPWR sky130_fd_sc_hd__tapvpwrvgnd_1
XFILLER_30_209 VGND VGND VPWR VPWR sky130_fd_sc_hd__decap_3
XFILLER_90_15 VGND VGND VPWR VPWR sky130_fd_sc_hd__decap_3
XFILLER_51_570 VGND VGND VPWR VPWR sky130_fd_sc_hd__decap_3
XFILLER_90_59 VGND VGND VPWR VPWR sky130_fd_sc_hd__fill_2
XTAP_TAPCELL_ROW_41_749 VGND VPWR sky130_fd_sc_hd__tapvpwrvgnd_1
XTAP_TAPCELL_ROW_41_738 VGND VPWR sky130_fd_sc_hd__tapvpwrvgnd_1
XTAP_TAPCELL_ROW_13_407 VGND VPWR sky130_fd_sc_hd__tapvpwrvgnd_1
XFILLER_7_449 VGND VGND VPWR VPWR sky130_fd_sc_hd__fill_2
XFILLER_109_377 VGND VGND VPWR VPWR sky130_fd_sc_hd__decap_3
XFILLER_3_600 VGND VGND VPWR VPWR sky130_fd_sc_hd__decap_3
XFILLER_3_644 VGND VGND VPWR VPWR sky130_fd_sc_hd__decap_3
XFILLER_105_550 VGND VGND VPWR VPWR sky130_fd_sc_hd__decap_3
XFILLER_105_561 VGND VGND VPWR VPWR sky130_fd_sc_hd__decap_3
XFILLER_2_154 VGND VGND VPWR VPWR sky130_fd_sc_hd__fill_2
XFILLER_3_688 VGND VGND VPWR VPWR sky130_fd_sc_hd__decap_3
XFILLER_105_594 VGND VGND VPWR VPWR sky130_fd_sc_hd__decap_3
XFILLER_2_176 VGND VGND VPWR VPWR sky130_fd_sc_hd__decap_3
XFILLER_2_187 VGND VGND VPWR VPWR sky130_fd_sc_hd__fill_2
XFILLER_38_309 VGND VGND VPWR VPWR sky130_fd_sc_hd__decap_3
XFILLER_48_50 VGND VGND VPWR VPWR sky130_fd_sc_hd__decap_3
XFILLER_66_607 VGND VGND VPWR VPWR sky130_fd_sc_hd__decap_3
XFILLER_48_83 VGND VGND VPWR VPWR sky130_fd_sc_hd__fill_1
Xsingle_cycle_cpu_579 VGND VGND VPWR VPWR instruction_out[0] single_cycle_cpu_579/LO
+ sky130_fd_sc_hd__conb_1
XTAP_TAPCELL_ROW_49_838 VGND VPWR sky130_fd_sc_hd__tapvpwrvgnd_1
XFILLER_0_13 VGND VGND VPWR VPWR sky130_fd_sc_hd__decap_3
XFILLER_19_534 VGND VGND VPWR VPWR sky130_fd_sc_hd__decap_3
XFILLER_74_640 VGND VGND VPWR VPWR sky130_fd_sc_hd__decap_3
XFILLER_74_651 VGND VGND VPWR VPWR sky130_fd_sc_hd__decap_3
XFILLER_0_57 VGND VGND VPWR VPWR sky130_fd_sc_hd__fill_2
XFILLER_19_567 VGND VGND VPWR VPWR sky130_fd_sc_hd__decap_3
XFILLER_73_150 VGND VGND VPWR VPWR sky130_fd_sc_hd__decap_3
XFILLER_74_684 VGND VGND VPWR VPWR sky130_fd_sc_hd__decap_3
XFILLER_34_559 VGND VGND VPWR VPWR sky130_fd_sc_hd__decap_3
XFILLER_61_323 VGND VGND VPWR VPWR sky130_fd_sc_hd__decap_3
XFILLER_64_82 VGND VGND VPWR VPWR sky130_fd_sc_hd__fill_2
XTAP_TAPCELL_ROW_29_595 VGND VPWR sky130_fd_sc_hd__tapvpwrvgnd_1
XFILLER_9_11 VGND VGND VPWR VPWR sky130_fd_sc_hd__decap_3
XFILLER_42_581 VGND VGND VPWR VPWR sky130_fd_sc_hd__decap_3
XFILLER_42_592 VGND VGND VPWR VPWR sky130_fd_sc_hd__decap_3
XFILLER_9_55 VGND VGND VPWR VPWR sky130_fd_sc_hd__fill_1
XFILLER_80_70 VGND VGND VPWR VPWR sky130_fd_sc_hd__fill_2
X_3610_ _3610_/A _3610_/B VGND VGND VPWR VPWR _3610_/Y sky130_fd_sc_hd__nor2_2
XPHY_EDGE_ROW_104_Right_104 VGND VGND VPWR VPWR sky130_fd_sc_hd__decap_3
X_3541_ _4376_/A _3541_/B _4460_/B VGND VGND VPWR VPWR _3541_/X sky130_fd_sc_hd__or3b_4
XFILLER_115_314 VGND VGND VPWR VPWR sky130_fd_sc_hd__decap_3
XFILLER_115_325 VGND VGND VPWR VPWR sky130_fd_sc_hd__decap_3
Xhold906 _6702_/Q VGND VGND VPWR VPWR hold906/X sky130_fd_sc_hd__dlygate4sd3_1
Xhold917 _6693_/Q VGND VGND VPWR VPWR hold917/X sky130_fd_sc_hd__dlygate4sd3_1
Xhold928 _7028_/Q VGND VGND VPWR VPWR hold928/X sky130_fd_sc_hd__dlygate4sd3_1
XFILLER_50_3 VGND VGND VPWR VPWR sky130_fd_sc_hd__decap_3
Xhold939 _6703_/Q VGND VGND VPWR VPWR hold939/X sky130_fd_sc_hd__dlygate4sd3_1
X_6260_ _6678_/A VGND VGND VPWR VPWR _6260_/Y sky130_fd_sc_hd__inv_2
X_3472_ _7216_/Q _3377_/X _4348_/B1 _7120_/Q VGND VGND VPWR VPWR _3472_/X sky130_fd_sc_hd__a22o_2
X_5211_ _5211_/A _5225_/B VGND VGND VPWR VPWR _7223_/D sky130_fd_sc_hd__and2_2
XFILLER_111_520 VGND VGND VPWR VPWR sky130_fd_sc_hd__decap_3
X_5142_ _5142_/A0 _3993_/X _5157_/S VGND VGND VPWR VPWR _7249_/D sky130_fd_sc_hd__mux2_2
XFILLER_111_553 VGND VGND VPWR VPWR sky130_fd_sc_hd__decap_3
XFILLER_111_564 VGND VGND VPWR VPWR sky130_fd_sc_hd__decap_3
XFILLER_96_253 VGND VGND VPWR VPWR sky130_fd_sc_hd__decap_3
XFILLER_111_597 VGND VGND VPWR VPWR sky130_fd_sc_hd__decap_3
XFILLER_57_629 VGND VGND VPWR VPWR sky130_fd_sc_hd__decap_3
XFILLER_96_297 VGND VGND VPWR VPWR sky130_fd_sc_hd__decap_3
X_5073_ _5073_/A _5073_/B VGND VGND VPWR VPWR _5073_/Y sky130_fd_sc_hd__xnor2_2
XTAP_TAPCELL_ROW_71_1099 VGND VPWR sky130_fd_sc_hd__tapvpwrvgnd_1
XFILLER_37_331 VGND VGND VPWR VPWR sky130_fd_sc_hd__decap_3
XFILLER_64_161 VGND VGND VPWR VPWR sky130_fd_sc_hd__decap_3
XFILLER_65_662 VGND VGND VPWR VPWR sky130_fd_sc_hd__decap_3
XFILLER_65_673 VGND VGND VPWR VPWR sky130_fd_sc_hd__decap_3
XFILLER_80_610 VGND VGND VPWR VPWR sky130_fd_sc_hd__decap_3
XFILLER_52_312 VGND VGND VPWR VPWR sky130_fd_sc_hd__decap_3
XFILLER_80_643 VGND VGND VPWR VPWR sky130_fd_sc_hd__fill_1
XFILLER_92_481 VGND VGND VPWR VPWR sky130_fd_sc_hd__fill_2
XFILLER_80_654 VGND VGND VPWR VPWR sky130_fd_sc_hd__decap_3
XFILLER_80_687 VGND VGND VPWR VPWR sky130_fd_sc_hd__decap_3
XFILLER_33_570 VGND VGND VPWR VPWR sky130_fd_sc_hd__decap_3
X_4926_ _4948_/A _4920_/Y _4925_/X VGND VGND VPWR VPWR _4926_/Y sky130_fd_sc_hd__o21ai_2
X_4857_ _4927_/A _5655_/D wire550/X VGND VGND VPWR VPWR _4857_/X sky130_fd_sc_hd__or3b_4
XFILLER_20_253 VGND VGND VPWR VPWR sky130_fd_sc_hd__decap_3
X_3808_ _6929_/Q _3921_/A2 _3922_/A2 _6793_/Q _3807_/X VGND VGND VPWR VPWR _3808_/X
+ sky130_fd_sc_hd__a221o_2
XFILLER_109_23 VGND VGND VPWR VPWR sky130_fd_sc_hd__decap_3
X_6527_ _6624_/A VGND VGND VPWR VPWR _6527_/Y sky130_fd_sc_hd__inv_2
X_4788_ _4788_/A _4788_/B VGND VGND VPWR VPWR _4788_/Y sky130_fd_sc_hd__nand2_2
X_3739_ _6936_/Q _3921_/A2 _3889_/A2 _6800_/Q VGND VGND VPWR VPWR _3739_/X sky130_fd_sc_hd__a22o_2
XFILLER_106_336 VGND VGND VPWR VPWR sky130_fd_sc_hd__decap_3
XFILLER_106_358 VGND VGND VPWR VPWR sky130_fd_sc_hd__decap_3
X_6458_ _6649_/A VGND VGND VPWR VPWR _6458_/Y sky130_fd_sc_hd__inv_2
X_6389_ _6654_/A VGND VGND VPWR VPWR _6389_/Y sky130_fd_sc_hd__inv_2
X_5409_ _5409_/A0 _5079_/X _5409_/S VGND VGND VPWR VPWR _7129_/D sky130_fd_sc_hd__mux2_2
XFILLER_102_531 VGND VGND VPWR VPWR sky130_fd_sc_hd__fill_1
XFILLER_87_220 VGND VGND VPWR VPWR sky130_fd_sc_hd__fill_1
XFILLER_102_542 VGND VGND VPWR VPWR sky130_fd_sc_hd__decap_3
XFILLER_48_607 VGND VGND VPWR VPWR sky130_fd_sc_hd__decap_3
XFILLER_75_404 VGND VGND VPWR VPWR sky130_fd_sc_hd__decap_3
XFILLER_102_575 VGND VGND VPWR VPWR sky130_fd_sc_hd__decap_3
XTAP_TAPCELL_ROW_89_1316 VGND VPWR sky130_fd_sc_hd__tapvpwrvgnd_1
XFILLER_56_640 VGND VGND VPWR VPWR sky130_fd_sc_hd__decap_3
XFILLER_56_651 VGND VGND VPWR VPWR sky130_fd_sc_hd__decap_3
XFILLER_56_684 VGND VGND VPWR VPWR sky130_fd_sc_hd__decap_3
XFILLER_90_407 VGND VGND VPWR VPWR sky130_fd_sc_hd__fill_2
XTAP_TAPCELL_ROW_46_808 VGND VPWR sky130_fd_sc_hd__tapvpwrvgnd_1
XFILLER_16_526 VGND VGND VPWR VPWR sky130_fd_sc_hd__decap_3
XFILLER_16_548 VGND VGND VPWR VPWR sky130_fd_sc_hd__decap_3
XFILLER_43_323 VGND VGND VPWR VPWR sky130_fd_sc_hd__decap_3
XFILLER_71_632 VGND VGND VPWR VPWR sky130_fd_sc_hd__decap_3
XFILLER_83_492 VGND VGND VPWR VPWR sky130_fd_sc_hd__fill_1
XFILLER_31_518 VGND VGND VPWR VPWR sky130_fd_sc_hd__decap_3
XFILLER_71_665 VGND VGND VPWR VPWR sky130_fd_sc_hd__decap_3
XFILLER_71_676 VGND VGND VPWR VPWR sky130_fd_sc_hd__decap_3
XFILLER_24_581 VGND VGND VPWR VPWR sky130_fd_sc_hd__decap_3
XFILLER_43_389 VGND VGND VPWR VPWR sky130_fd_sc_hd__decap_3
XTAP_TAPCELL_ROW_54_896 VGND VPWR sky130_fd_sc_hd__tapvpwrvgnd_1
XTAP_TAPCELL_ROW_26_565 VGND VPWR sky130_fd_sc_hd__tapvpwrvgnd_1
XFILLER_11_231 VGND VGND VPWR VPWR sky130_fd_sc_hd__fill_1
XFILLER_24_592 VGND VGND VPWR VPWR sky130_fd_sc_hd__decap_3
XFILLER_11_253 VGND VGND VPWR VPWR sky130_fd_sc_hd__fill_1
XFILLER_7_202 VGND VGND VPWR VPWR sky130_fd_sc_hd__decap_3
XFILLER_7_268 VGND VGND VPWR VPWR sky130_fd_sc_hd__decap_3
XFILLER_112_306 VGND VGND VPWR VPWR sky130_fd_sc_hd__fill_2
XFILLER_98_507 VGND VGND VPWR VPWR sky130_fd_sc_hd__decap_3
XFILLER_3_496 VGND VGND VPWR VPWR sky130_fd_sc_hd__decap_3
XFILLER_59_60 VGND VGND VPWR VPWR sky130_fd_sc_hd__decap_3
XFILLER_78_253 VGND VGND VPWR VPWR sky130_fd_sc_hd__decap_3
XFILLER_38_128 VGND VGND VPWR VPWR sky130_fd_sc_hd__decap_3
XFILLER_39_629 VGND VGND VPWR VPWR sky130_fd_sc_hd__decap_3
XFILLER_15_6 VGND VGND VPWR VPWR sky130_fd_sc_hd__fill_1
XFILLER_78_297 VGND VGND VPWR VPWR sky130_fd_sc_hd__decap_3
XFILLER_46_150 VGND VGND VPWR VPWR sky130_fd_sc_hd__fill_2
XFILLER_47_662 VGND VGND VPWR VPWR sky130_fd_sc_hd__decap_3
XFILLER_47_673 VGND VGND VPWR VPWR sky130_fd_sc_hd__decap_3
XTAP_TAPCELL_ROW_109_1563 VGND VPWR sky130_fd_sc_hd__tapvpwrvgnd_1
XFILLER_19_386 VGND VGND VPWR VPWR sky130_fd_sc_hd__decap_3
XFILLER_62_610 VGND VGND VPWR VPWR sky130_fd_sc_hd__decap_3
XFILLER_62_643 VGND VGND VPWR VPWR sky130_fd_sc_hd__fill_1
XFILLER_34_345 VGND VGND VPWR VPWR sky130_fd_sc_hd__decap_3
XFILLER_62_654 VGND VGND VPWR VPWR sky130_fd_sc_hd__decap_3
XFILLER_15_570 VGND VGND VPWR VPWR sky130_fd_sc_hd__decap_3
XFILLER_62_687 VGND VGND VPWR VPWR sky130_fd_sc_hd__decap_3
XFILLER_98_3 VGND VGND VPWR VPWR sky130_fd_sc_hd__decap_3
X_4711_ _7005_/Q _7006_/Q _4775_/A VGND VGND VPWR VPWR _4738_/A sky130_fd_sc_hd__and3_2
XFILLER_30_573 VGND VGND VPWR VPWR sky130_fd_sc_hd__decap_3
X_4642_ _4207_/A _4642_/B VGND VGND VPWR VPWR _4888_/A sky130_fd_sc_hd__and2b_2
XFILLER_30_595 VGND VGND VPWR VPWR sky130_fd_sc_hd__decap_3
XFILLER_116_612 VGND VGND VPWR VPWR sky130_fd_sc_hd__decap_3
X_7361_ _7362_/CLK _7361_/D _6641_/Y VGND VGND VPWR VPWR _7361_/Q sky130_fd_sc_hd__dfrtp_2
Xhold703 _6790_/Q VGND VGND VPWR VPWR _6790_/D sky130_fd_sc_hd__dlygate4sd3_1
X_4573_ _7294_/Q _4595_/B VGND VGND VPWR VPWR _7294_/D sky130_fd_sc_hd__and2_2
XFILLER_115_111 VGND VGND VPWR VPWR sky130_fd_sc_hd__fill_1
XFILLER_115_122 VGND VGND VPWR VPWR sky130_fd_sc_hd__decap_3
XFILLER_116_634 VGND VGND VPWR VPWR sky130_fd_sc_hd__decap_3
XFILLER_116_656 VGND VGND VPWR VPWR sky130_fd_sc_hd__decap_3
X_7292_ _7328_/CLK _7292_/D _6572_/Y VGND VGND VPWR VPWR _7292_/Q sky130_fd_sc_hd__dfrtp_2
Xhold714 _6846_/Q VGND VGND VPWR VPWR _6846_/D sky130_fd_sc_hd__dlygate4sd3_1
Xhold725 _6850_/Q VGND VGND VPWR VPWR _6850_/D sky130_fd_sc_hd__dlygate4sd3_1
Xhold736 _6793_/Q VGND VGND VPWR VPWR _6793_/D sky130_fd_sc_hd__dlygate4sd3_1
X_6312_ _6632_/A VGND VGND VPWR VPWR _6312_/Y sky130_fd_sc_hd__inv_2
XFILLER_115_155 VGND VGND VPWR VPWR sky130_fd_sc_hd__decap_3
XFILLER_89_529 VGND VGND VPWR VPWR sky130_fd_sc_hd__decap_3
Xhold747 _6844_/Q VGND VGND VPWR VPWR _6844_/D sky130_fd_sc_hd__dlygate4sd3_1
Xhold758 _6845_/Q VGND VGND VPWR VPWR _6845_/D sky130_fd_sc_hd__dlygate4sd3_1
Xhold769 _6794_/Q VGND VGND VPWR VPWR _6794_/D sky130_fd_sc_hd__dlygate4sd3_1
X_3455_ _7346_/Q _4337_/B _3454_/X VGND VGND VPWR VPWR _3455_/X sky130_fd_sc_hd__a21o_2
XTAP_TAPCELL_ROW_73_1128 VGND VPWR sky130_fd_sc_hd__tapvpwrvgnd_1
XFILLER_69_220 VGND VGND VPWR VPWR sky130_fd_sc_hd__decap_3
XFILLER_69_231 VGND VGND VPWR VPWR sky130_fd_sc_hd__decap_3
X_3386_ _3561_/A _3386_/B VGND VGND VPWR VPWR _3386_/Y sky130_fd_sc_hd__nand2_2
XFILLER_111_350 VGND VGND VPWR VPWR sky130_fd_sc_hd__fill_1
XFILLER_57_415 VGND VGND VPWR VPWR sky130_fd_sc_hd__fill_1
XFILLER_69_275 VGND VGND VPWR VPWR sky130_fd_sc_hd__decap_3
XFILLER_97_573 VGND VGND VPWR VPWR sky130_fd_sc_hd__decap_3
X_5125_ _5156_/S _5125_/B VGND VGND VPWR VPWR _5125_/Y sky130_fd_sc_hd__nand2_2
XFILLER_38_640 VGND VGND VPWR VPWR sky130_fd_sc_hd__decap_3
XFILLER_57_437 VGND VGND VPWR VPWR sky130_fd_sc_hd__fill_2
XFILLER_69_297 VGND VGND VPWR VPWR sky130_fd_sc_hd__decap_3
X_5056_ _3536_/B _4619_/B _5052_/X _5055_/X VGND VGND VPWR VPWR _5056_/X sky130_fd_sc_hd__o31a_2
XFILLER_38_651 VGND VGND VPWR VPWR sky130_fd_sc_hd__decap_3
XFILLER_55_18 VGND VGND VPWR VPWR sky130_fd_sc_hd__fill_2
XFILLER_84_256 VGND VGND VPWR VPWR sky130_fd_sc_hd__decap_3
XFILLER_25_312 VGND VGND VPWR VPWR sky130_fd_sc_hd__decap_3
XFILLER_25_323 VGND VGND VPWR VPWR sky130_fd_sc_hd__decap_3
XFILLER_37_172 VGND VGND VPWR VPWR sky130_fd_sc_hd__decap_3
XFILLER_38_684 VGND VGND VPWR VPWR sky130_fd_sc_hd__decap_3
XFILLER_53_632 VGND VGND VPWR VPWR sky130_fd_sc_hd__decap_3
XFILLER_111_24 VGND VGND VPWR VPWR sky130_fd_sc_hd__decap_3
XFILLER_52_153 VGND VGND VPWR VPWR sky130_fd_sc_hd__decap_3
XFILLER_53_665 VGND VGND VPWR VPWR sky130_fd_sc_hd__decap_3
XFILLER_53_676 VGND VGND VPWR VPWR sky130_fd_sc_hd__decap_3
XFILLER_80_451 VGND VGND VPWR VPWR sky130_fd_sc_hd__fill_1
XTAP_TAPCELL_ROW_84_1257 VGND VPWR sky130_fd_sc_hd__tapvpwrvgnd_1
XFILLER_111_57 VGND VGND VPWR VPWR sky130_fd_sc_hd__decap_3
XFILLER_40_315 VGND VGND VPWR VPWR sky130_fd_sc_hd__decap_3
XFILLER_52_197 VGND VGND VPWR VPWR sky130_fd_sc_hd__decap_3
X_4909_ _4960_/A _4909_/B _4909_/C VGND VGND VPWR VPWR _4910_/B sky130_fd_sc_hd__or3_2
XTAP_TAPCELL_ROW_23_524 VGND VPWR sky130_fd_sc_hd__tapvpwrvgnd_1
XFILLER_21_573 VGND VGND VPWR VPWR sky130_fd_sc_hd__decap_3
XTAP_TAPCELL_ROW_51_866 VGND VPWR sky130_fd_sc_hd__tapvpwrvgnd_1
XFILLER_107_612 VGND VGND VPWR VPWR sky130_fd_sc_hd__decap_3
XFILLER_107_623 VGND VGND VPWR VPWR sky130_fd_sc_hd__decap_3
XFILLER_106_111 VGND VGND VPWR VPWR sky130_fd_sc_hd__decap_3
XFILLER_107_656 VGND VGND VPWR VPWR sky130_fd_sc_hd__decap_3
XTAP_TAPCELL_ROW_95_1397 VGND VPWR sky130_fd_sc_hd__tapvpwrvgnd_1
XTAP_TAPCELL_ROW_95_1386 VGND VPWR sky130_fd_sc_hd__tapvpwrvgnd_1
XFILLER_106_177 VGND VGND VPWR VPWR sky130_fd_sc_hd__decap_3
XFILLER_0_444 VGND VGND VPWR VPWR sky130_fd_sc_hd__decap_3
XFILLER_88_551 VGND VGND VPWR VPWR sky130_fd_sc_hd__decap_3
XFILLER_0_466 VGND VGND VPWR VPWR sky130_fd_sc_hd__fill_2
XFILLER_0_477 VGND VGND VPWR VPWR sky130_fd_sc_hd__decap_3
XFILLER_48_415 VGND VGND VPWR VPWR sky130_fd_sc_hd__decap_3
XFILLER_75_201 VGND VGND VPWR VPWR sky130_fd_sc_hd__decap_3
XFILLER_88_584 VGND VGND VPWR VPWR sky130_fd_sc_hd__decap_3
XFILLER_88_595 VGND VGND VPWR VPWR sky130_fd_sc_hd__decap_3
XFILLER_0_499 VGND VGND VPWR VPWR sky130_fd_sc_hd__decap_3
XFILLER_75_234 VGND VGND VPWR VPWR sky130_fd_sc_hd__decap_3
XTAP_TAPCELL_ROW_59_955 VGND VPWR sky130_fd_sc_hd__tapvpwrvgnd_1
XFILLER_28_150 VGND VGND VPWR VPWR sky130_fd_sc_hd__decap_3
XFILLER_29_662 VGND VGND VPWR VPWR sky130_fd_sc_hd__decap_3
XFILLER_29_673 VGND VGND VPWR VPWR sky130_fd_sc_hd__decap_3
XFILLER_75_278 VGND VGND VPWR VPWR sky130_fd_sc_hd__fill_2
XFILLER_28_183 VGND VGND VPWR VPWR sky130_fd_sc_hd__decap_3
XFILLER_44_610 VGND VGND VPWR VPWR sky130_fd_sc_hd__decap_3
Xplace407 _4534_/S VGND VGND VPWR VPWR _4269_/B1 sky130_fd_sc_hd__buf_2
Xplace418 _3958_/S VGND VGND VPWR VPWR _3954_/S sky130_fd_sc_hd__buf_2
Xplace429 _3368_/Y VGND VGND VPWR VPWR _3394_/A sky130_fd_sc_hd__buf_2
XTAP_TAPCELL_ROW_3_293 VGND VPWR sky130_fd_sc_hd__tapvpwrvgnd_1
XTAP_TAPCELL_ROW_3_282 VGND VPWR sky130_fd_sc_hd__tapvpwrvgnd_1
XFILLER_44_643 VGND VGND VPWR VPWR sky130_fd_sc_hd__fill_1
XFILLER_44_654 VGND VGND VPWR VPWR sky130_fd_sc_hd__decap_3
XFILLER_44_687 VGND VGND VPWR VPWR sky130_fd_sc_hd__decap_3
XFILLER_31_337 VGND VGND VPWR VPWR sky130_fd_sc_hd__decap_3
XFILLER_31_359 VGND VGND VPWR VPWR sky130_fd_sc_hd__decap_3
XFILLER_12_551 VGND VGND VPWR VPWR sky130_fd_sc_hd__decap_3
XFILLER_8_522 VGND VGND VPWR VPWR sky130_fd_sc_hd__decap_3
XFILLER_12_584 VGND VGND VPWR VPWR sky130_fd_sc_hd__decap_3
XFILLER_12_595 VGND VGND VPWR VPWR sky130_fd_sc_hd__decap_3
XFILLER_8_533 VGND VGND VPWR VPWR sky130_fd_sc_hd__decap_3
XFILLER_6_12 VGND VGND VPWR VPWR sky130_fd_sc_hd__fill_2
XFILLER_8_566 VGND VGND VPWR VPWR sky130_fd_sc_hd__decap_3
XANTENNA_5 _7390_/Q VGND VGND VPWR VPWR sky130_fd_sc_hd__diode_2
XFILLER_6_67 VGND VGND VPWR VPWR sky130_fd_sc_hd__fill_1
XFILLER_113_615 VGND VGND VPWR VPWR sky130_fd_sc_hd__fill_1
XFILLER_98_304 VGND VGND VPWR VPWR sky130_fd_sc_hd__decap_3
XFILLER_113_626 VGND VGND VPWR VPWR sky130_fd_sc_hd__decap_3
XFILLER_98_326 VGND VGND VPWR VPWR sky130_fd_sc_hd__fill_1
XFILLER_113_659 VGND VGND VPWR VPWR sky130_fd_sc_hd__decap_3
XFILLER_79_551 VGND VGND VPWR VPWR sky130_fd_sc_hd__decap_3
XFILLER_100_309 VGND VGND VPWR VPWR sky130_fd_sc_hd__decap_3
XFILLER_112_169 VGND VGND VPWR VPWR sky130_fd_sc_hd__decap_3
XFILLER_79_573 VGND VGND VPWR VPWR sky130_fd_sc_hd__decap_3
XFILLER_39_459 VGND VGND VPWR VPWR sky130_fd_sc_hd__decap_3
XFILLER_66_212 VGND VGND VPWR VPWR sky130_fd_sc_hd__fill_2
XFILLER_94_554 VGND VGND VPWR VPWR sky130_fd_sc_hd__decap_3
XFILLER_66_256 VGND VGND VPWR VPWR sky130_fd_sc_hd__decap_3
XFILLER_94_587 VGND VGND VPWR VPWR sky130_fd_sc_hd__fill_1
XFILLER_19_183 VGND VGND VPWR VPWR sky130_fd_sc_hd__decap_3
XFILLER_35_632 VGND VGND VPWR VPWR sky130_fd_sc_hd__decap_3
XFILLER_81_237 VGND VGND VPWR VPWR sky130_fd_sc_hd__decap_3
XFILLER_94_598 VGND VGND VPWR VPWR sky130_fd_sc_hd__decap_3
X_6930_ clkload8/A _6930_/D VGND VGND VPWR VPWR _6930_/Q sky130_fd_sc_hd__dfxtp_2
XFILLER_35_665 VGND VGND VPWR VPWR sky130_fd_sc_hd__decap_3
XFILLER_62_451 VGND VGND VPWR VPWR sky130_fd_sc_hd__decap_3
X_6861_ _6978_/CLK _6861_/D VGND VGND VPWR VPWR _6861_/Q sky130_fd_sc_hd__dfxtp_2
XFILLER_22_315 VGND VGND VPWR VPWR sky130_fd_sc_hd__decap_3
XFILLER_35_676 VGND VGND VPWR VPWR sky130_fd_sc_hd__decap_3
XFILLER_50_613 VGND VGND VPWR VPWR sky130_fd_sc_hd__decap_3
X_6792_ _6965_/CLK _6792_/D VGND VGND VPWR VPWR _6792_/Q sky130_fd_sc_hd__dfxtp_2
XFILLER_22_326 VGND VGND VPWR VPWR sky130_fd_sc_hd__decap_3
XFILLER_50_657 VGND VGND VPWR VPWR sky130_fd_sc_hd__decap_3
XFILLER_30_381 VGND VGND VPWR VPWR sky130_fd_sc_hd__decap_3
X_5674_ _7343_/Q hold927/X _5703_/S VGND VGND VPWR VPWR _6687_/D sky130_fd_sc_hd__mux2_2
X_4625_ _5099_/A wire555/X _4624_/B _4624_/X VGND VGND VPWR VPWR _4916_/A sky130_fd_sc_hd__a31oi_4
X_7344_ _7344_/CLK _7344_/D _6624_/Y VGND VGND VPWR VPWR _7344_/Q sky130_fd_sc_hd__dfrtp_2
X_4556_ _7302_/Q _4577_/B VGND VGND VPWR VPWR _7302_/D sky130_fd_sc_hd__and2_2
XFILLER_104_604 VGND VGND VPWR VPWR sky130_fd_sc_hd__decap_3
XFILLER_116_442 VGND VGND VPWR VPWR sky130_fd_sc_hd__decap_3
X_3507_ _3458_/Y _3505_/X _3506_/Y VGND VGND VPWR VPWR _3508_/B sky130_fd_sc_hd__o21a_2
XFILLER_104_637 VGND VGND VPWR VPWR sky130_fd_sc_hd__decap_3
XFILLER_104_648 VGND VGND VPWR VPWR sky130_fd_sc_hd__decap_3
XFILLER_116_486 VGND VGND VPWR VPWR sky130_fd_sc_hd__decap_3
XFILLER_89_337 VGND VGND VPWR VPWR sky130_fd_sc_hd__fill_1
X_7275_ _7307_/CLK _7275_/D _6555_/Y VGND VGND VPWR VPWR _7275_/Q sky130_fd_sc_hd__dfrtp_2
Xhold588 _6808_/Q VGND VGND VPWR VPWR _6808_/D sky130_fd_sc_hd__dlygate4sd3_1
XFILLER_103_125 VGND VGND VPWR VPWR sky130_fd_sc_hd__decap_3
XFILLER_106_35 VGND VGND VPWR VPWR sky130_fd_sc_hd__decap_3
XFILLER_89_359 VGND VGND VPWR VPWR sky130_fd_sc_hd__decap_3
Xhold599 _6898_/Q VGND VGND VPWR VPWR _6898_/D sky130_fd_sc_hd__dlygate4sd3_1
X_3438_ _7314_/Q _3989_/S _4338_/B1 _7346_/Q _4248_/A VGND VGND VPWR VPWR _3438_/X
+ sky130_fd_sc_hd__a221o_2
XFILLER_103_169 VGND VGND VPWR VPWR sky130_fd_sc_hd__decap_3
XFILLER_112_681 VGND VGND VPWR VPWR sky130_fd_sc_hd__decap_3
Xhold1200 _7379_/Q VGND VGND VPWR VPWR _3909_/A1 sky130_fd_sc_hd__dlygate4sd3_1
X_3369_ _3371_/A _5668_/A VGND VGND VPWR VPWR _3560_/B sky130_fd_sc_hd__nand2_2
XFILLER_85_521 VGND VGND VPWR VPWR sky130_fd_sc_hd__decap_3
XFILLER_85_554 VGND VGND VPWR VPWR sky130_fd_sc_hd__decap_3
Xhold1211 _7317_/Q VGND VGND VPWR VPWR _4524_/A0 sky130_fd_sc_hd__dlygate4sd3_1
Xhold1222 _7175_/Q VGND VGND VPWR VPWR _5310_/A0 sky130_fd_sc_hd__dlygate4sd3_1
X_5108_ _5108_/A0 _5107_/X _5108_/S VGND VGND VPWR VPWR _7255_/D sky130_fd_sc_hd__mux2_2
XFILLER_57_267 VGND VGND VPWR VPWR sky130_fd_sc_hd__decap_3
XFILLER_85_576 VGND VGND VPWR VPWR sky130_fd_sc_hd__decap_3
XFILLER_26_610 VGND VGND VPWR VPWR sky130_fd_sc_hd__decap_3
XFILLER_45_429 VGND VGND VPWR VPWR sky130_fd_sc_hd__decap_3
XFILLER_72_215 VGND VGND VPWR VPWR sky130_fd_sc_hd__decap_3
X_5039_ _4677_/B _3856_/X _5658_/B _5038_/X _5647_/A VGND VGND VPWR VPWR _5039_/X
+ sky130_fd_sc_hd__o32a_2
XTAP_TAPCELL_ROW_56_925 VGND VPWR sky130_fd_sc_hd__tapvpwrvgnd_1
XFILLER_26_643 VGND VGND VPWR VPWR sky130_fd_sc_hd__fill_1
XFILLER_26_654 VGND VGND VPWR VPWR sky130_fd_sc_hd__decap_3
XFILLER_72_248 VGND VGND VPWR VPWR sky130_fd_sc_hd__decap_3
XFILLER_72_259 VGND VGND VPWR VPWR sky130_fd_sc_hd__decap_3
XFILLER_82_27 VGND VGND VPWR VPWR sky130_fd_sc_hd__fill_1
XTAP_TAPCELL_ROW_0_252 VGND VPWR sky130_fd_sc_hd__tapvpwrvgnd_1
XTAP_TAPCELL_ROW_0_241 VGND VPWR sky130_fd_sc_hd__tapvpwrvgnd_1
XFILLER_15_32 VGND VGND VPWR VPWR sky130_fd_sc_hd__decap_3
XFILLER_26_687 VGND VGND VPWR VPWR sky130_fd_sc_hd__decap_3
XFILLER_53_473 VGND VGND VPWR VPWR sky130_fd_sc_hd__decap_3
XFILLER_80_270 VGND VGND VPWR VPWR sky130_fd_sc_hd__fill_2
XFILLER_13_337 VGND VGND VPWR VPWR sky130_fd_sc_hd__decap_3
XFILLER_41_635 VGND VGND VPWR VPWR sky130_fd_sc_hd__decap_3
XFILLER_80_292 VGND VGND VPWR VPWR sky130_fd_sc_hd__decap_3
XTAP_TAPCELL_ROW_36_682 VGND VPWR sky130_fd_sc_hd__tapvpwrvgnd_1
XFILLER_41_668 VGND VGND VPWR VPWR sky130_fd_sc_hd__decap_3
XFILLER_41_679 VGND VGND VPWR VPWR sky130_fd_sc_hd__decap_3
XTAP_TAPCELL_ROW_97_1415 VGND VPWR sky130_fd_sc_hd__tapvpwrvgnd_1
XFILLER_31_20 VGND VGND VPWR VPWR sky130_fd_sc_hd__fill_2
XFILLER_5_514 VGND VGND VPWR VPWR sky130_fd_sc_hd__decap_3
XFILLER_5_547 VGND VGND VPWR VPWR sky130_fd_sc_hd__decap_3
XFILLER_107_464 VGND VGND VPWR VPWR sky130_fd_sc_hd__decap_3
XFILLER_107_497 VGND VGND VPWR VPWR sky130_fd_sc_hd__decap_3
XFILLER_110_607 VGND VGND VPWR VPWR sky130_fd_sc_hd__decap_3
XTAP_TAPCELL_ROW_8_352 VGND VPWR sky130_fd_sc_hd__tapvpwrvgnd_1
XFILLER_0_241 VGND VGND VPWR VPWR sky130_fd_sc_hd__decap_3
XFILLER_48_212 VGND VGND VPWR VPWR sky130_fd_sc_hd__fill_1
XFILLER_36_407 VGND VGND VPWR VPWR sky130_fd_sc_hd__decap_3
XFILLER_48_256 VGND VGND VPWR VPWR sky130_fd_sc_hd__decap_3
XFILLER_48_278 VGND VGND VPWR VPWR sky130_fd_sc_hd__decap_3
XFILLER_76_554 VGND VGND VPWR VPWR sky130_fd_sc_hd__decap_3
XFILLER_76_587 VGND VGND VPWR VPWR sky130_fd_sc_hd__fill_1
XFILLER_17_632 VGND VGND VPWR VPWR sky130_fd_sc_hd__decap_3
XFILLER_29_481 VGND VGND VPWR VPWR sky130_fd_sc_hd__decap_3
XFILLER_63_204 VGND VGND VPWR VPWR sky130_fd_sc_hd__decap_3
XFILLER_63_237 VGND VGND VPWR VPWR sky130_fd_sc_hd__decap_3
XFILLER_76_598 VGND VGND VPWR VPWR sky130_fd_sc_hd__decap_3
XFILLER_91_546 VGND VGND VPWR VPWR sky130_fd_sc_hd__decap_3
XFILLER_17_665 VGND VGND VPWR VPWR sky130_fd_sc_hd__decap_3
XFILLER_91_579 VGND VGND VPWR VPWR sky130_fd_sc_hd__decap_3
Xplace204 _3562_/B VGND VGND VPWR VPWR place204/X sky130_fd_sc_hd__buf_2
XTAP_TAPCELL_ROW_106_1522 VGND VPWR sky130_fd_sc_hd__tapvpwrvgnd_1
XFILLER_17_676 VGND VGND VPWR VPWR sky130_fd_sc_hd__decap_3
XFILLER_32_613 VGND VGND VPWR VPWR sky130_fd_sc_hd__decap_3
XFILLER_44_451 VGND VGND VPWR VPWR sky130_fd_sc_hd__decap_3
XFILLER_44_473 VGND VGND VPWR VPWR sky130_fd_sc_hd__decap_3
XFILLER_16_197 VGND VGND VPWR VPWR sky130_fd_sc_hd__decap_3
XFILLER_32_657 VGND VGND VPWR VPWR sky130_fd_sc_hd__decap_3
XFILLER_71_281 VGND VGND VPWR VPWR sky130_fd_sc_hd__decap_3
XFILLER_40_690 VGND VGND VPWR VPWR sky130_fd_sc_hd__fill_1
XFILLER_82_6 VGND VGND VPWR VPWR sky130_fd_sc_hd__fill_1
XFILLER_8_396 VGND VGND VPWR VPWR sky130_fd_sc_hd__decap_3
X_4410_ _4411_/A _4411_/B VGND VGND VPWR VPWR _4788_/B sky130_fd_sc_hd__nor2_2
X_5390_ _5390_/A0 _4932_/X _5409_/S VGND VGND VPWR VPWR _7138_/D sky130_fd_sc_hd__mux2_2
XFILLER_113_423 VGND VGND VPWR VPWR sky130_fd_sc_hd__decap_3
X_4341_ _7255_/Q _4601_/S _4348_/B1 _7127_/Q _4340_/X VGND VGND VPWR VPWR _4365_/A
+ sky130_fd_sc_hd__a221o_2
XFILLER_99_635 VGND VGND VPWR VPWR sky130_fd_sc_hd__decap_3
XFILLER_98_112 VGND VGND VPWR VPWR sky130_fd_sc_hd__decap_3
X_7060_ _7311_/CLK _7060_/D _6340_/Y VGND VGND VPWR VPWR _7060_/Q sky130_fd_sc_hd__dfrtp_2
X_4272_ _4394_/A _4312_/B _4271_/X VGND VGND VPWR VPWR _4273_/D sky130_fd_sc_hd__or3b_2
XFILLER_99_679 VGND VGND VPWR VPWR sky130_fd_sc_hd__decap_3
XFILLER_99_668 VGND VGND VPWR VPWR sky130_fd_sc_hd__decap_3
XFILLER_101_629 VGND VGND VPWR VPWR sky130_fd_sc_hd__decap_3
XFILLER_113_467 VGND VGND VPWR VPWR sky130_fd_sc_hd__decap_3
XFILLER_86_318 VGND VGND VPWR VPWR sky130_fd_sc_hd__decap_3
XFILLER_100_117 VGND VGND VPWR VPWR sky130_fd_sc_hd__decap_3
XFILLER_79_381 VGND VGND VPWR VPWR sky130_fd_sc_hd__decap_3
XFILLER_39_245 VGND VGND VPWR VPWR sky130_fd_sc_hd__decap_3
XFILLER_67_576 VGND VGND VPWR VPWR sky130_fd_sc_hd__decap_3
XFILLER_54_215 VGND VGND VPWR VPWR sky130_fd_sc_hd__fill_1
XFILLER_54_237 VGND VGND VPWR VPWR sky130_fd_sc_hd__decap_3
XFILLER_82_557 VGND VGND VPWR VPWR sky130_fd_sc_hd__decap_3
X_6913_ _6965_/CLK _6913_/D VGND VGND VPWR VPWR _6913_/Q sky130_fd_sc_hd__dfxtp_2
XFILLER_23_635 VGND VGND VPWR VPWR sky130_fd_sc_hd__decap_3
XFILLER_50_421 VGND VGND VPWR VPWR sky130_fd_sc_hd__decap_3
X_6844_ _6974_/CLK _6844_/D VGND VGND VPWR VPWR _6844_/Q sky130_fd_sc_hd__dfxtp_2
XTAP_TAPCELL_ROW_81_1227 VGND VPWR sky130_fd_sc_hd__tapvpwrvgnd_1
XFILLER_23_668 VGND VGND VPWR VPWR sky130_fd_sc_hd__decap_3
XFILLER_23_679 VGND VGND VPWR VPWR sky130_fd_sc_hd__decap_3
X_6775_ _6968_/CLK _6775_/D VGND VGND VPWR VPWR _6775_/Q sky130_fd_sc_hd__dfxtp_2
X_3987_ _7347_/Q _4528_/A _3987_/S VGND VGND VPWR VPWR _7347_/D sky130_fd_sc_hd__mux2_2
XTAP_TAPCELL_ROW_33_652 VGND VPWR sky130_fd_sc_hd__tapvpwrvgnd_1
XFILLER_10_318 VGND VGND VPWR VPWR sky130_fd_sc_hd__decap_3
XFILLER_22_189 VGND VGND VPWR VPWR sky130_fd_sc_hd__fill_1
XTAP_TAPCELL_ROW_61_983 VGND VPWR sky130_fd_sc_hd__tapvpwrvgnd_1
X_5657_ _5657_/A _5657_/B _5657_/C _5657_/D VGND VGND VPWR VPWR _5664_/C sky130_fd_sc_hd__nor4_2
X_4608_ _4938_/A _4608_/B VGND VGND VPWR VPWR _4608_/Y sky130_fd_sc_hd__nor2_2
XFILLER_104_412 VGND VGND VPWR VPWR sky130_fd_sc_hd__fill_2
XFILLER_116_250 VGND VGND VPWR VPWR sky130_fd_sc_hd__fill_2
XFILLER_116_261 VGND VGND VPWR VPWR sky130_fd_sc_hd__fill_2
XFILLER_2_528 VGND VGND VPWR VPWR sky130_fd_sc_hd__decap_3
XFILLER_2_539 VGND VGND VPWR VPWR sky130_fd_sc_hd__decap_3
X_7327_ _7364_/CLK _7327_/D _6607_/Y VGND VGND VPWR VPWR _7327_/Q sky130_fd_sc_hd__dfrtp_2
XFILLER_89_134 VGND VGND VPWR VPWR sky130_fd_sc_hd__decap_3
X_7258_ _7392_/CLK _7258_/D _6538_/Y VGND VGND VPWR VPWR _7258_/Q sky130_fd_sc_hd__dfrtp_2
XTAP_TAPCELL_ROW_92_1356 VGND VPWR sky130_fd_sc_hd__tapvpwrvgnd_1
XFILLER_104_489 VGND VGND VPWR VPWR sky130_fd_sc_hd__decap_3
XFILLER_77_307 VGND VGND VPWR VPWR sky130_fd_sc_hd__decap_3
XFILLER_77_318 VGND VGND VPWR VPWR sky130_fd_sc_hd__decap_3
XTAP_TAPCELL_ROW_5_311 VGND VPWR sky130_fd_sc_hd__tapvpwrvgnd_1
X_7189_ _7383_/CLK _7189_/D _6469_/Y VGND VGND VPWR VPWR _7189_/Q sky130_fd_sc_hd__dfrtp_2
XFILLER_98_690 VGND VGND VPWR VPWR sky130_fd_sc_hd__fill_1
XFILLER_100_640 VGND VGND VPWR VPWR sky130_fd_sc_hd__decap_3
XFILLER_100_651 VGND VGND VPWR VPWR sky130_fd_sc_hd__decap_3
XFILLER_58_565 VGND VGND VPWR VPWR sky130_fd_sc_hd__decap_3
XFILLER_85_340 VGND VGND VPWR VPWR sky130_fd_sc_hd__fill_2
XFILLER_93_15 VGND VGND VPWR VPWR sky130_fd_sc_hd__decap_3
Xhold1030 _7246_/Q VGND VGND VPWR VPWR _5163_/A sky130_fd_sc_hd__dlygate4sd3_1
Xhold1041 _7391_/Q VGND VGND VPWR VPWR _3814_/A1 sky130_fd_sc_hd__dlygate4sd3_1
XFILLER_100_684 VGND VGND VPWR VPWR sky130_fd_sc_hd__decap_3
XFILLER_58_598 VGND VGND VPWR VPWR sky130_fd_sc_hd__decap_3
XFILLER_73_513 VGND VGND VPWR VPWR sky130_fd_sc_hd__fill_1
Xhold1052 _7276_/Q VGND VGND VPWR VPWR _4753_/A0 sky130_fd_sc_hd__dlygate4sd3_1
Xhold1063 _7335_/Q VGND VGND VPWR VPWR _4488_/A0 sky130_fd_sc_hd__dlygate4sd3_1
Xhold1074 _7387_/Q VGND VGND VPWR VPWR _3857_/A1 sky130_fd_sc_hd__dlygate4sd3_1
Xhold1085 _7256_/Q VGND VGND VPWR VPWR _5095_/A0 sky130_fd_sc_hd__dlygate4sd3_1
Xhold1096 _7384_/Q VGND VGND VPWR VPWR _3868_/A1 sky130_fd_sc_hd__dlygate4sd3_1
XFILLER_14_613 VGND VGND VPWR VPWR sky130_fd_sc_hd__decap_3
XFILLER_73_579 VGND VGND VPWR VPWR sky130_fd_sc_hd__decap_3
Xclkbuf_3_6__f_clk clkbuf_0_clk/X VGND VGND VPWR VPWR clkload4/A sky130_fd_sc_hd__clkbuf_16
XFILLER_14_657 VGND VGND VPWR VPWR sky130_fd_sc_hd__decap_3
XFILLER_26_495 VGND VGND VPWR VPWR sky130_fd_sc_hd__fill_1
XFILLER_53_270 VGND VGND VPWR VPWR sky130_fd_sc_hd__decap_3
XFILLER_53_281 VGND VGND VPWR VPWR sky130_fd_sc_hd__decap_3
XFILLER_13_167 VGND VGND VPWR VPWR sky130_fd_sc_hd__fill_1
XFILLER_13_178 VGND VGND VPWR VPWR sky130_fd_sc_hd__fill_2
XTAP_TAPCELL_ROW_101_1463 VGND VPWR sky130_fd_sc_hd__tapvpwrvgnd_1
XFILLER_22_690 VGND VGND VPWR VPWR sky130_fd_sc_hd__fill_1
XFILLER_42_74 VGND VGND VPWR VPWR sky130_fd_sc_hd__fill_2
XTAP_TAPCELL_ROW_11_379 VGND VPWR sky130_fd_sc_hd__tapvpwrvgnd_1
XFILLER_1_550 VGND VGND VPWR VPWR sky130_fd_sc_hd__decap_3
XFILLER_1_561 VGND VGND VPWR VPWR sky130_fd_sc_hd__fill_1
XFILLER_96_616 VGND VGND VPWR VPWR sky130_fd_sc_hd__decap_3
XFILLER_110_448 VGND VGND VPWR VPWR sky130_fd_sc_hd__decap_3
XFILLER_1_583 VGND VGND VPWR VPWR sky130_fd_sc_hd__decap_3
XFILLER_3_57 VGND VGND VPWR VPWR sky130_fd_sc_hd__decap_3
XFILLER_95_126 VGND VGND VPWR VPWR sky130_fd_sc_hd__fill_1
XFILLER_95_148 VGND VGND VPWR VPWR sky130_fd_sc_hd__fill_2
XTAP_TAPCELL_ROW_112_1592 VGND VPWR sky130_fd_sc_hd__tapvpwrvgnd_1
XFILLER_49_576 VGND VGND VPWR VPWR sky130_fd_sc_hd__decap_3
XFILLER_67_93 VGND VGND VPWR VPWR sky130_fd_sc_hd__decap_3
XFILLER_36_215 VGND VGND VPWR VPWR sky130_fd_sc_hd__decap_3
XFILLER_36_248 VGND VGND VPWR VPWR sky130_fd_sc_hd__decap_3
XFILLER_36_259 VGND VGND VPWR VPWR sky130_fd_sc_hd__fill_1
XFILLER_64_557 VGND VGND VPWR VPWR sky130_fd_sc_hd__decap_3
XFILLER_91_387 VGND VGND VPWR VPWR sky130_fd_sc_hd__decap_3
XTAP_TAPCELL_ROW_67_1060 VGND VPWR sky130_fd_sc_hd__tapvpwrvgnd_1
XTAP_TAPCELL_ROW_19_479 VGND VPWR sky130_fd_sc_hd__tapvpwrvgnd_1
XFILLER_44_270 VGND VGND VPWR VPWR sky130_fd_sc_hd__decap_3
X_4890_ _5101_/A _4890_/B VGND VGND VPWR VPWR _4890_/Y sky130_fd_sc_hd__nor2_2
X_3910_ _6916_/Q _3921_/A2 _3922_/A2 _6780_/Q VGND VGND VPWR VPWR _3910_/X sky130_fd_sc_hd__a22o_2
XFILLER_20_616 VGND VGND VPWR VPWR sky130_fd_sc_hd__decap_3
X_3841_ _6845_/Q _3886_/A2 _3890_/B1 _6830_/Q _3840_/X VGND VGND VPWR VPWR _3841_/X
+ sky130_fd_sc_hd__a221o_2
X_6560_ _6633_/A VGND VGND VPWR VPWR _6560_/Y sky130_fd_sc_hd__inv_2
X_3772_ _6854_/Q _3889_/B1 _3883_/B1 _6902_/Q _3771_/X VGND VGND VPWR VPWR _3772_/X
+ sky130_fd_sc_hd__a221o_2
XTAP_TAPCELL_ROW_30_611 VGND VPWR sky130_fd_sc_hd__tapvpwrvgnd_1
XFILLER_9_650 VGND VGND VPWR VPWR sky130_fd_sc_hd__decap_3
X_6491_ _6673_/A VGND VGND VPWR VPWR _6491_/Y sky130_fd_sc_hd__inv_2
X_5373_ _5373_/A0 _4792_/X _5383_/S VGND VGND VPWR VPWR _7146_/D sky130_fd_sc_hd__mux2_2
X_7112_ _7368_/CLK _7112_/D _6392_/Y VGND VGND VPWR VPWR _7112_/Q sky130_fd_sc_hd__dfrtp_2
Xoutput468 _5657_/C VGND VGND VPWR VPWR alu_result_out[18] sky130_fd_sc_hd__clkdlybuf4s25_1
X_4324_ _7039_/Q _4488_/S _4437_/B1 _7386_/Q VGND VGND VPWR VPWR _4324_/X sky130_fd_sc_hd__a22o_2
XFILLER_101_404 VGND VGND VPWR VPWR sky130_fd_sc_hd__decap_3
XFILLER_101_415 VGND VGND VPWR VPWR sky130_fd_sc_hd__decap_3
X_7043_ _7362_/CLK _7043_/D _6323_/Y VGND VGND VPWR VPWR _7043_/Q sky130_fd_sc_hd__dfrtp_2
Xoutput479 _5663_/A VGND VGND VPWR VPWR alu_result_out[28] sky130_fd_sc_hd__clkdlybuf4s25_1
XFILLER_113_297 VGND VGND VPWR VPWR sky130_fd_sc_hd__decap_3
XFILLER_86_115 VGND VGND VPWR VPWR sky130_fd_sc_hd__fill_2
XFILLER_87_638 VGND VGND VPWR VPWR sky130_fd_sc_hd__decap_3
X_4255_ _4251_/X _4254_/X _4327_/A VGND VGND VPWR VPWR _4256_/C sky130_fd_sc_hd__o21ai_2
XFILLER_99_498 VGND VGND VPWR VPWR sky130_fd_sc_hd__decap_3
XFILLER_67_351 VGND VGND VPWR VPWR sky130_fd_sc_hd__decap_3
X_4186_ _4186_/A _4636_/B VGND VGND VPWR VPWR _4186_/Y sky130_fd_sc_hd__xnor2_2
XFILLER_95_671 VGND VGND VPWR VPWR sky130_fd_sc_hd__fill_1
XFILLER_95_682 VGND VGND VPWR VPWR sky130_fd_sc_hd__decap_3
XTAP_TAPCELL_ROW_38_711 VGND VPWR sky130_fd_sc_hd__tapvpwrvgnd_1
XFILLER_82_321 VGND VGND VPWR VPWR sky130_fd_sc_hd__decap_3
XFILLER_42_207 VGND VGND VPWR VPWR sky130_fd_sc_hd__fill_1
XFILLER_55_579 VGND VGND VPWR VPWR sky130_fd_sc_hd__decap_3
XFILLER_63_18 VGND VGND VPWR VPWR sky130_fd_sc_hd__decap_3
XFILLER_70_549 VGND VGND VPWR VPWR sky130_fd_sc_hd__decap_3
X_6827_ _6970_/CLK _6827_/D VGND VGND VPWR VPWR _6827_/Q sky130_fd_sc_hd__dfxtp_2
XFILLER_11_638 VGND VGND VPWR VPWR sky130_fd_sc_hd__decap_3
XFILLER_50_262 VGND VGND VPWR VPWR sky130_fd_sc_hd__decap_3
XFILLER_7_609 VGND VGND VPWR VPWR sky130_fd_sc_hd__decap_3
X_6758_ _6959_/CLK _6758_/D VGND VGND VPWR VPWR _6758_/Q sky130_fd_sc_hd__dfxtp_2
XFILLER_109_526 VGND VGND VPWR VPWR sky130_fd_sc_hd__decap_3
XFILLER_6_119 VGND VGND VPWR VPWR sky130_fd_sc_hd__decap_3
X_6689_ _6965_/CLK _6689_/D VGND VGND VPWR VPWR _6689_/Q sky130_fd_sc_hd__dfxtp_2
XFILLER_109_559 VGND VGND VPWR VPWR sky130_fd_sc_hd__fill_1
XFILLER_12_77 VGND VGND VPWR VPWR sky130_fd_sc_hd__decap_3
XFILLER_88_26 VGND VGND VPWR VPWR sky130_fd_sc_hd__fill_2
XFILLER_104_253 VGND VGND VPWR VPWR sky130_fd_sc_hd__decap_3
XFILLER_78_616 VGND VGND VPWR VPWR sky130_fd_sc_hd__decap_3
XFILLER_104_286 VGND VGND VPWR VPWR sky130_fd_sc_hd__decap_3
XFILLER_86_660 VGND VGND VPWR VPWR sky130_fd_sc_hd__decap_3
XFILLER_100_470 VGND VGND VPWR VPWR sky130_fd_sc_hd__decap_3
XFILLER_92_107 VGND VGND VPWR VPWR sky130_fd_sc_hd__decap_3
XFILLER_100_492 VGND VGND VPWR VPWR sky130_fd_sc_hd__decap_3
XFILLER_37_74 VGND VGND VPWR VPWR sky130_fd_sc_hd__decap_3
XFILLER_58_395 VGND VGND VPWR VPWR sky130_fd_sc_hd__decap_3
XFILLER_73_321 VGND VGND VPWR VPWR sky130_fd_sc_hd__decap_3
XFILLER_73_343 VGND VGND VPWR VPWR sky130_fd_sc_hd__decap_3
XFILLER_33_218 VGND VGND VPWR VPWR sky130_fd_sc_hd__decap_3
XFILLER_46_579 VGND VGND VPWR VPWR sky130_fd_sc_hd__decap_3
XFILLER_61_505 VGND VGND VPWR VPWR sky130_fd_sc_hd__decap_3
XFILLER_14_410 VGND VGND VPWR VPWR sky130_fd_sc_hd__decap_3
XFILLER_14_421 VGND VGND VPWR VPWR sky130_fd_sc_hd__decap_3
XFILLER_26_281 VGND VGND VPWR VPWR sky130_fd_sc_hd__decap_3
XTAP_TAPCELL_ROW_16_438 VGND VPWR sky130_fd_sc_hd__tapvpwrvgnd_1
XFILLER_41_240 VGND VGND VPWR VPWR sky130_fd_sc_hd__fill_2
XTAP_TAPCELL_ROW_16_449 VGND VPWR sky130_fd_sc_hd__tapvpwrvgnd_1
XFILLER_41_284 VGND VGND VPWR VPWR sky130_fd_sc_hd__decap_3
XFILLER_10_660 VGND VGND VPWR VPWR sky130_fd_sc_hd__decap_3
XFILLER_6_631 VGND VGND VPWR VPWR sky130_fd_sc_hd__decap_3
XFILLER_115_529 VGND VGND VPWR VPWR sky130_fd_sc_hd__decap_3
XFILLER_6_675 VGND VGND VPWR VPWR sky130_fd_sc_hd__decap_3
XTAP_TAPCELL_ROW_114_1621 VGND VPWR sky130_fd_sc_hd__tapvpwrvgnd_1
XFILLER_108_581 VGND VGND VPWR VPWR sky130_fd_sc_hd__decap_3
XFILLER_108_592 VGND VGND VPWR VPWR sky130_fd_sc_hd__decap_3
XFILLER_45_6 VGND VGND VPWR VPWR sky130_fd_sc_hd__fill_2
XFILLER_5_196 VGND VGND VPWR VPWR sky130_fd_sc_hd__decap_3
XFILLER_1_380 VGND VGND VPWR VPWR sky130_fd_sc_hd__fill_1
XFILLER_68_137 VGND VGND VPWR VPWR sky130_fd_sc_hd__decap_3
XFILLER_69_638 VGND VGND VPWR VPWR sky130_fd_sc_hd__decap_3
XFILLER_49_340 VGND VGND VPWR VPWR sky130_fd_sc_hd__decap_3
XFILLER_68_159 VGND VGND VPWR VPWR sky130_fd_sc_hd__decap_3
XFILLER_84_619 VGND VGND VPWR VPWR sky130_fd_sc_hd__decap_3
X_4040_ _4608_/B _4040_/B VGND VGND VPWR VPWR _4040_/Y sky130_fd_sc_hd__nor2_2
XFILLER_77_671 VGND VGND VPWR VPWR sky130_fd_sc_hd__fill_1
XFILLER_77_682 VGND VGND VPWR VPWR sky130_fd_sc_hd__decap_3
XFILLER_64_332 VGND VGND VPWR VPWR sky130_fd_sc_hd__decap_3
XFILLER_76_181 VGND VGND VPWR VPWR sky130_fd_sc_hd__fill_2
XFILLER_37_579 VGND VGND VPWR VPWR sky130_fd_sc_hd__decap_3
XFILLER_52_527 VGND VGND VPWR VPWR sky130_fd_sc_hd__fill_2
XFILLER_64_365 VGND VGND VPWR VPWR sky130_fd_sc_hd__decap_3
XFILLER_91_140 VGND VGND VPWR VPWR sky130_fd_sc_hd__decap_3
XFILLER_92_663 VGND VGND VPWR VPWR sky130_fd_sc_hd__decap_3
XFILLER_17_281 VGND VGND VPWR VPWR sky130_fd_sc_hd__fill_2
X_4942_ _6995_/Q _4960_/B _4677_/B _3403_/A VGND VGND VPWR VPWR _4943_/B sky130_fd_sc_hd__o211ai_2
XFILLER_32_240 VGND VGND VPWR VPWR sky130_fd_sc_hd__fill_1
XFILLER_32_251 VGND VGND VPWR VPWR sky130_fd_sc_hd__fill_1
XFILLER_32_284 VGND VGND VPWR VPWR sky130_fd_sc_hd__decap_3
XFILLER_60_582 VGND VGND VPWR VPWR sky130_fd_sc_hd__decap_3
X_6612_ _6612_/A VGND VGND VPWR VPWR _6612_/Y sky130_fd_sc_hd__inv_2
X_4873_ _4764_/B _4111_/B _4845_/A _5101_/A VGND VGND VPWR VPWR _4873_/X sky130_fd_sc_hd__o22a_2
XFILLER_20_446 VGND VGND VPWR VPWR sky130_fd_sc_hd__decap_3
XFILLER_32_295 VGND VGND VPWR VPWR sky130_fd_sc_hd__decap_3
X_3824_ _6965_/Q _3918_/A2 _3926_/B1 _6953_/Q _3823_/X VGND VGND VPWR VPWR _3824_/X
+ sky130_fd_sc_hd__a221o_2
X_6543_ _6642_/A VGND VGND VPWR VPWR _6543_/Y sky130_fd_sc_hd__inv_2
X_3755_ _6934_/Q _3768_/A2 _3925_/B1 _6886_/Q VGND VGND VPWR VPWR _3755_/X sky130_fd_sc_hd__a22o_2
XFILLER_9_480 VGND VGND VPWR VPWR sky130_fd_sc_hd__decap_3
XFILLER_106_507 VGND VGND VPWR VPWR sky130_fd_sc_hd__decap_3
X_6474_ _6638_/A VGND VGND VPWR VPWR _6474_/Y sky130_fd_sc_hd__inv_2
X_5425_ _5425_/A0 _3993_/X _5425_/S VGND VGND VPWR VPWR _7121_/D sky130_fd_sc_hd__mux2_2
XPHY_EDGE_ROW_12_Right_12 VGND VGND VPWR VPWR sky130_fd_sc_hd__decap_3
XTAP_TAPCELL_ROW_76_1159 VGND VPWR sky130_fd_sc_hd__tapvpwrvgnd_1
XFILLER_114_551 VGND VGND VPWR VPWR sky130_fd_sc_hd__decap_3
XFILLER_58_29 VGND VGND VPWR VPWR sky130_fd_sc_hd__fill_2
XFILLER_87_402 VGND VGND VPWR VPWR sky130_fd_sc_hd__decap_3
X_5356_ _5356_/A0 _3993_/X _7412_/A VGND VGND VPWR VPWR _7153_/D sky130_fd_sc_hd__mux2_2
XFILLER_99_240 VGND VGND VPWR VPWR sky130_fd_sc_hd__fill_1
XFILLER_101_223 VGND VGND VPWR VPWR sky130_fd_sc_hd__fill_1
XFILLER_114_584 VGND VGND VPWR VPWR sky130_fd_sc_hd__decap_3
XFILLER_114_595 VGND VGND VPWR VPWR sky130_fd_sc_hd__decap_3
X_4307_ _7224_/Q _4331_/A2 _4300_/B _7037_/Q VGND VGND VPWR VPWR _4307_/X sky130_fd_sc_hd__a22o_2
XFILLER_101_256 VGND VGND VPWR VPWR sky130_fd_sc_hd__fill_1
XFILLER_114_24 VGND VGND VPWR VPWR sky130_fd_sc_hd__decap_3
X_7026_ _7372_/CLK _7026_/D _6306_/Y VGND VGND VPWR VPWR _7026_/Q sky130_fd_sc_hd__dfrtp_2
X_4238_ _7067_/Q _4305_/B _4460_/A _4237_/X VGND VGND VPWR VPWR _4629_/B sky130_fd_sc_hd__o211ai_2
XFILLER_101_278 VGND VGND VPWR VPWR sky130_fd_sc_hd__fill_2
XFILLER_114_35 VGND VGND VPWR VPWR sky130_fd_sc_hd__decap_3
XFILLER_55_310 VGND VGND VPWR VPWR sky130_fd_sc_hd__decap_3
XFILLER_68_660 VGND VGND VPWR VPWR sky130_fd_sc_hd__decap_3
XFILLER_74_118 VGND VGND VPWR VPWR sky130_fd_sc_hd__decap_3
XFILLER_114_68 VGND VGND VPWR VPWR sky130_fd_sc_hd__decap_3
XFILLER_28_557 VGND VGND VPWR VPWR sky130_fd_sc_hd__decap_3
XFILLER_83_641 VGND VGND VPWR VPWR sky130_fd_sc_hd__decap_3
X_4169_ _4165_/X _4168_/X _4327_/A VGND VGND VPWR VPWR _4202_/A sky130_fd_sc_hd__o21a_2
XFILLER_83_685 VGND VGND VPWR VPWR sky130_fd_sc_hd__decap_3
XPHY_EDGE_ROW_21_Right_21 VGND VGND VPWR VPWR sky130_fd_sc_hd__decap_3
XFILLER_70_324 VGND VGND VPWR VPWR sky130_fd_sc_hd__decap_3
XFILLER_82_173 VGND VGND VPWR VPWR sky130_fd_sc_hd__decap_3
XTAP_TAPCELL_ROW_87_1299 VGND VPWR sky130_fd_sc_hd__tapvpwrvgnd_1
XFILLER_70_368 VGND VGND VPWR VPWR sky130_fd_sc_hd__decap_3
XFILLER_70_379 VGND VGND VPWR VPWR sky130_fd_sc_hd__fill_2
XFILLER_11_402 VGND VGND VPWR VPWR sky130_fd_sc_hd__decap_3
XFILLER_23_273 VGND VGND VPWR VPWR sky130_fd_sc_hd__decap_3
XFILLER_51_582 VGND VGND VPWR VPWR sky130_fd_sc_hd__decap_3
XFILLER_90_38 VGND VGND VPWR VPWR sky130_fd_sc_hd__decap_3
XTAP_TAPCELL_ROW_41_739 VGND VPWR sky130_fd_sc_hd__tapvpwrvgnd_1
XTAP_TAPCELL_ROW_13_408 VGND VPWR sky130_fd_sc_hd__tapvpwrvgnd_1
XFILLER_11_446 VGND VGND VPWR VPWR sky130_fd_sc_hd__fill_2
XFILLER_7_406 VGND VGND VPWR VPWR sky130_fd_sc_hd__decap_3
XFILLER_23_65 VGND VGND VPWR VPWR sky130_fd_sc_hd__decap_3
XPHY_EDGE_ROW_30_Right_30 VGND VGND VPWR VPWR sky130_fd_sc_hd__decap_3
XFILLER_3_612 VGND VGND VPWR VPWR sky130_fd_sc_hd__decap_3
XFILLER_99_69 VGND VGND VPWR VPWR sky130_fd_sc_hd__decap_3
XFILLER_3_623 VGND VGND VPWR VPWR sky130_fd_sc_hd__decap_3
XFILLER_2_144 VGND VGND VPWR VPWR sky130_fd_sc_hd__fill_2
XFILLER_3_656 VGND VGND VPWR VPWR sky130_fd_sc_hd__decap_3
XFILLER_105_573 VGND VGND VPWR VPWR sky130_fd_sc_hd__decap_3
XFILLER_78_424 VGND VGND VPWR VPWR sky130_fd_sc_hd__decap_3
XFILLER_66_619 VGND VGND VPWR VPWR sky130_fd_sc_hd__decap_3
XFILLER_78_446 VGND VGND VPWR VPWR sky130_fd_sc_hd__fill_2
XFILLER_78_457 VGND VGND VPWR VPWR sky130_fd_sc_hd__decap_3
XFILLER_93_405 VGND VGND VPWR VPWR sky130_fd_sc_hd__decap_3
XFILLER_59_671 VGND VGND VPWR VPWR sky130_fd_sc_hd__fill_1
XFILLER_59_682 VGND VGND VPWR VPWR sky130_fd_sc_hd__decap_3
XTAP_TAPCELL_ROW_49_839 VGND VPWR sky130_fd_sc_hd__tapvpwrvgnd_1
XFILLER_19_546 VGND VGND VPWR VPWR sky130_fd_sc_hd__decap_3
XFILLER_46_332 VGND VGND VPWR VPWR sky130_fd_sc_hd__decap_3
XFILLER_19_579 VGND VGND VPWR VPWR sky130_fd_sc_hd__decap_3
XFILLER_61_302 VGND VGND VPWR VPWR sky130_fd_sc_hd__decap_3
XFILLER_74_663 VGND VGND VPWR VPWR sky130_fd_sc_hd__decap_3
XTAP_TAPCELL_ROW_29_596 VGND VPWR sky130_fd_sc_hd__tapvpwrvgnd_1
XFILLER_42_560 VGND VGND VPWR VPWR sky130_fd_sc_hd__decap_3
XFILLER_80_82 VGND VGND VPWR VPWR sky130_fd_sc_hd__fill_2
X_3540_ _3502_/A _3502_/B _3485_/C VGND VGND VPWR VPWR _3540_/X sky130_fd_sc_hd__o21a_2
Xhold907 _6696_/Q VGND VGND VPWR VPWR hold907/X sky130_fd_sc_hd__dlygate4sd3_1
Xhold918 _6708_/Q VGND VGND VPWR VPWR hold918/X sky130_fd_sc_hd__dlygate4sd3_1
XFILLER_6_483 VGND VGND VPWR VPWR sky130_fd_sc_hd__decap_3
Xhold929 _7030_/Q VGND VGND VPWR VPWR _5595_/A sky130_fd_sc_hd__dlygate4sd3_1
X_3471_ _3545_/A _3545_/B VGND VGND VPWR VPWR _3505_/A sky130_fd_sc_hd__and2b_2
XFILLER_115_359 VGND VGND VPWR VPWR sky130_fd_sc_hd__decap_3
XFILLER_96_221 VGND VGND VPWR VPWR sky130_fd_sc_hd__decap_3
XFILLER_111_532 VGND VGND VPWR VPWR sky130_fd_sc_hd__decap_3
XFILLER_69_446 VGND VGND VPWR VPWR sky130_fd_sc_hd__fill_2
X_5072_ _5114_/A _5072_/B _5072_/C VGND VGND VPWR VPWR _5075_/B sky130_fd_sc_hd__and3_2
XFILLER_111_576 VGND VGND VPWR VPWR sky130_fd_sc_hd__decap_3
XFILLER_37_310 VGND VGND VPWR VPWR sky130_fd_sc_hd__decap_3
XFILLER_65_641 VGND VGND VPWR VPWR sky130_fd_sc_hd__decap_3
XFILLER_25_516 VGND VGND VPWR VPWR sky130_fd_sc_hd__decap_3
XFILLER_65_685 VGND VGND VPWR VPWR sky130_fd_sc_hd__decap_3
XFILLER_64_173 VGND VGND VPWR VPWR sky130_fd_sc_hd__decap_3
XFILLER_64_195 VGND VGND VPWR VPWR sky130_fd_sc_hd__fill_1
XFILLER_80_622 VGND VGND VPWR VPWR sky130_fd_sc_hd__decap_3
XFILLER_52_368 VGND VGND VPWR VPWR sky130_fd_sc_hd__fill_1
XFILLER_80_666 VGND VGND VPWR VPWR sky130_fd_sc_hd__decap_3
XFILLER_100_15 VGND VGND VPWR VPWR sky130_fd_sc_hd__decap_3
XFILLER_33_582 VGND VGND VPWR VPWR sky130_fd_sc_hd__decap_3
X_4925_ _4764_/B _4158_/A _4920_/A _5101_/A _4924_/X VGND VGND VPWR VPWR _4925_/X
+ sky130_fd_sc_hd__o221a_2
XFILLER_20_232 VGND VGND VPWR VPWR sky130_fd_sc_hd__decap_3
XFILLER_20_243 VGND VGND VPWR VPWR sky130_fd_sc_hd__decap_3
X_3807_ _6703_/Q _5660_/B _3887_/B1 _6881_/Q VGND VGND VPWR VPWR _3807_/X sky130_fd_sc_hd__a22o_2
X_6526_ _6558_/A VGND VGND VPWR VPWR _6526_/Y sky130_fd_sc_hd__inv_2
X_4787_ _4787_/A _4787_/B VGND VGND VPWR VPWR _4787_/Y sky130_fd_sc_hd__xnor2_2
XFILLER_109_35 VGND VGND VPWR VPWR sky130_fd_sc_hd__decap_3
XFILLER_114_9 VGND VGND VPWR VPWR sky130_fd_sc_hd__decap_3
X_3738_ _6740_/Q _3922_/A2 _5660_/B _6734_/Q _3737_/X VGND VGND VPWR VPWR _3738_/X
+ sky130_fd_sc_hd__a221o_2
XFILLER_106_348 VGND VGND VPWR VPWR sky130_fd_sc_hd__fill_1
XFILLER_109_57 VGND VGND VPWR VPWR sky130_fd_sc_hd__decap_3
XFILLER_109_68 VGND VGND VPWR VPWR sky130_fd_sc_hd__decap_3
XFILLER_69_28 VGND VGND VPWR VPWR sky130_fd_sc_hd__decap_3
X_6457_ _6649_/A VGND VGND VPWR VPWR _6457_/Y sky130_fd_sc_hd__inv_2
X_3669_ _6807_/Q _3918_/B1 _3917_/A2 _6717_/Q _3668_/X VGND VGND VPWR VPWR _3669_/X
+ sky130_fd_sc_hd__a221o_2
X_6388_ _6612_/A VGND VGND VPWR VPWR _6388_/Y sky130_fd_sc_hd__inv_2
XFILLER_0_615 VGND VGND VPWR VPWR sky130_fd_sc_hd__fill_1
XFILLER_0_637 VGND VGND VPWR VPWR sky130_fd_sc_hd__decap_3
XFILLER_102_510 VGND VGND VPWR VPWR sky130_fd_sc_hd__decap_3
XFILLER_0_648 VGND VGND VPWR VPWR sky130_fd_sc_hd__decap_3
XFILLER_102_554 VGND VGND VPWR VPWR sky130_fd_sc_hd__decap_3
XFILLER_114_392 VGND VGND VPWR VPWR sky130_fd_sc_hd__decap_3
XFILLER_102_587 VGND VGND VPWR VPWR sky130_fd_sc_hd__fill_1
XFILLER_102_598 VGND VGND VPWR VPWR sky130_fd_sc_hd__decap_3
XFILLER_48_619 VGND VGND VPWR VPWR sky130_fd_sc_hd__decap_3
XFILLER_75_427 VGND VGND VPWR VPWR sky130_fd_sc_hd__decap_3
XTAP_TAPCELL_ROW_89_1317 VGND VPWR sky130_fd_sc_hd__tapvpwrvgnd_1
XFILLER_28_332 VGND VGND VPWR VPWR sky130_fd_sc_hd__decap_3
XFILLER_75_449 VGND VGND VPWR VPWR sky130_fd_sc_hd__decap_3
X_7009_ _7403_/CLK _7009_/D _6289_/Y VGND VGND VPWR VPWR _7009_/Q sky130_fd_sc_hd__dfrtp_2
XFILLER_28_365 VGND VGND VPWR VPWR sky130_fd_sc_hd__decap_3
XFILLER_56_663 VGND VGND VPWR VPWR sky130_fd_sc_hd__decap_3
XFILLER_71_600 VGND VGND VPWR VPWR sky130_fd_sc_hd__decap_3
XFILLER_83_460 VGND VGND VPWR VPWR sky130_fd_sc_hd__decap_3
XTAP_TAPCELL_ROW_46_809 VGND VPWR sky130_fd_sc_hd__tapvpwrvgnd_1
XFILLER_28_376 VGND VGND VPWR VPWR sky130_fd_sc_hd__decap_3
XFILLER_43_302 VGND VGND VPWR VPWR sky130_fd_sc_hd__decap_3
XFILLER_43_335 VGND VGND VPWR VPWR sky130_fd_sc_hd__fill_1
XFILLER_71_644 VGND VGND VPWR VPWR sky130_fd_sc_hd__decap_3
XFILLER_31_508 VGND VGND VPWR VPWR sky130_fd_sc_hd__fill_2
XFILLER_43_346 VGND VGND VPWR VPWR sky130_fd_sc_hd__fill_1
XFILLER_70_154 VGND VGND VPWR VPWR sky130_fd_sc_hd__decap_3
XFILLER_24_560 VGND VGND VPWR VPWR sky130_fd_sc_hd__decap_3
XFILLER_71_688 VGND VGND VPWR VPWR sky130_fd_sc_hd__decap_3
XTAP_TAPCELL_ROW_54_897 VGND VPWR sky130_fd_sc_hd__tapvpwrvgnd_1
XTAP_TAPCELL_ROW_26_566 VGND VPWR sky130_fd_sc_hd__tapvpwrvgnd_1
XFILLER_11_265 VGND VGND VPWR VPWR sky130_fd_sc_hd__decap_3
XFILLER_7_225 VGND VGND VPWR VPWR sky130_fd_sc_hd__decap_3
XFILLER_50_85 VGND VGND VPWR VPWR sky130_fd_sc_hd__decap_3
XFILLER_3_453 VGND VGND VPWR VPWR sky130_fd_sc_hd__decap_3
XFILLER_98_519 VGND VGND VPWR VPWR sky130_fd_sc_hd__decap_3
XFILLER_112_318 VGND VGND VPWR VPWR sky130_fd_sc_hd__decap_3
XFILLER_3_475 VGND VGND VPWR VPWR sky130_fd_sc_hd__decap_3
XFILLER_59_72 VGND VGND VPWR VPWR sky130_fd_sc_hd__decap_3
XFILLER_66_427 VGND VGND VPWR VPWR sky130_fd_sc_hd__decap_3
XFILLER_78_265 VGND VGND VPWR VPWR sky130_fd_sc_hd__decap_3
XFILLER_93_202 VGND VGND VPWR VPWR sky130_fd_sc_hd__decap_3
XFILLER_47_641 VGND VGND VPWR VPWR sky130_fd_sc_hd__decap_3
XFILLER_59_490 VGND VGND VPWR VPWR sky130_fd_sc_hd__decap_3
XFILLER_19_354 VGND VGND VPWR VPWR sky130_fd_sc_hd__fill_2
XFILLER_19_365 VGND VGND VPWR VPWR sky130_fd_sc_hd__fill_1
XFILLER_75_82 VGND VGND VPWR VPWR sky130_fd_sc_hd__decap_3
XFILLER_93_268 VGND VGND VPWR VPWR sky130_fd_sc_hd__fill_2
XFILLER_93_279 VGND VGND VPWR VPWR sky130_fd_sc_hd__fill_1
XTAP_TAPCELL_ROW_109_1564 VGND VPWR sky130_fd_sc_hd__tapvpwrvgnd_1
XFILLER_47_685 VGND VGND VPWR VPWR sky130_fd_sc_hd__decap_3
XFILLER_62_622 VGND VGND VPWR VPWR sky130_fd_sc_hd__decap_3
XFILLER_34_357 VGND VGND VPWR VPWR sky130_fd_sc_hd__fill_1
XFILLER_61_121 VGND VGND VPWR VPWR sky130_fd_sc_hd__decap_3
XFILLER_62_666 VGND VGND VPWR VPWR sky130_fd_sc_hd__decap_3
XFILLER_15_582 VGND VGND VPWR VPWR sky130_fd_sc_hd__decap_3
X_5690_ _7351_/Q hold933/X _5708_/S VGND VGND VPWR VPWR _6695_/D sky130_fd_sc_hd__mux2_2
X_4710_ _7004_/Q _4801_/A VGND VGND VPWR VPWR _4775_/A sky130_fd_sc_hd__and2_2
X_4641_ _4920_/A _4379_/B _4640_/Y _4158_/A VGND VGND VPWR VPWR _4903_/B sky130_fd_sc_hd__o31a_2
XFILLER_30_585 VGND VGND VPWR VPWR sky130_fd_sc_hd__decap_3
X_7360_ _7364_/CLK _7360_/D _6640_/Y VGND VGND VPWR VPWR _7360_/Q sky130_fd_sc_hd__dfrtp_2
X_7291_ _7355_/CLK _7291_/D _6571_/Y VGND VGND VPWR VPWR _7291_/Q sky130_fd_sc_hd__dfrtp_2
Xhold704 _6736_/Q VGND VGND VPWR VPWR _6736_/D sky130_fd_sc_hd__dlygate4sd3_1
Xhold715 _6929_/Q VGND VGND VPWR VPWR _6929_/D sky130_fd_sc_hd__dlygate4sd3_1
Xhold726 _6744_/Q VGND VGND VPWR VPWR _6744_/D sky130_fd_sc_hd__dlygate4sd3_1
Xhold737 _6869_/Q VGND VGND VPWR VPWR _6869_/D sky130_fd_sc_hd__dlygate4sd3_1
X_6311_ _6602_/A VGND VGND VPWR VPWR _6311_/Y sky130_fd_sc_hd__inv_2
X_3523_ _3505_/A _3458_/Y _3505_/B _3506_/Y _3508_/A VGND VGND VPWR VPWR _3620_/A
+ sky130_fd_sc_hd__o311a_4
XFILLER_115_134 VGND VGND VPWR VPWR sky130_fd_sc_hd__decap_3
XFILLER_116_679 VGND VGND VPWR VPWR sky130_fd_sc_hd__decap_3
XFILLER_6_291 VGND VGND VPWR VPWR sky130_fd_sc_hd__decap_3
XFILLER_89_508 VGND VGND VPWR VPWR sky130_fd_sc_hd__fill_2
Xhold748 _6737_/Q VGND VGND VPWR VPWR _6737_/D sky130_fd_sc_hd__dlygate4sd3_1
Xhold759 _6968_/Q VGND VGND VPWR VPWR _6968_/D sky130_fd_sc_hd__dlygate4sd3_1
X_3454_ _7186_/Q _3989_/S _4300_/B _7031_/Q _3453_/X VGND VGND VPWR VPWR _3454_/X
+ sky130_fd_sc_hd__a221o_2
XTAP_TAPCELL_ROW_73_1129 VGND VPWR sky130_fd_sc_hd__tapvpwrvgnd_1
XFILLER_115_178 VGND VGND VPWR VPWR sky130_fd_sc_hd__decap_3
XFILLER_97_541 VGND VGND VPWR VPWR sky130_fd_sc_hd__decap_3
X_3385_ _6983_/Q _5130_/A VGND VGND VPWR VPWR _3385_/Y sky130_fd_sc_hd__nor2_2
XFILLER_69_254 VGND VGND VPWR VPWR sky130_fd_sc_hd__decap_3
XFILLER_97_585 VGND VGND VPWR VPWR sky130_fd_sc_hd__decap_3
X_5124_ _3746_/B _3900_/Y _4677_/B VGND VGND VPWR VPWR _5125_/B sky130_fd_sc_hd__a21o_2
XFILLER_57_449 VGND VGND VPWR VPWR sky130_fd_sc_hd__decap_3
XFILLER_84_246 VGND VGND VPWR VPWR sky130_fd_sc_hd__decap_3
X_5055_ _4811_/C _5049_/X _5053_/Y _5054_/Y _4369_/A VGND VGND VPWR VPWR _5055_/X
+ sky130_fd_sc_hd__a221o_2
XFILLER_38_663 VGND VGND VPWR VPWR sky130_fd_sc_hd__decap_3
XFILLER_53_600 VGND VGND VPWR VPWR sky130_fd_sc_hd__decap_3
XFILLER_84_268 VGND VGND VPWR VPWR sky130_fd_sc_hd__decap_3
XFILLER_65_482 VGND VGND VPWR VPWR sky130_fd_sc_hd__decap_3
XFILLER_111_36 VGND VGND VPWR VPWR sky130_fd_sc_hd__decap_3
XFILLER_53_644 VGND VGND VPWR VPWR sky130_fd_sc_hd__decap_3
XFILLER_92_290 VGND VGND VPWR VPWR sky130_fd_sc_hd__decap_3
XTAP_TAPCELL_ROW_84_1258 VGND VPWR sky130_fd_sc_hd__tapvpwrvgnd_1
XFILLER_111_69 VGND VGND VPWR VPWR sky130_fd_sc_hd__decap_3
XFILLER_53_688 VGND VGND VPWR VPWR sky130_fd_sc_hd__decap_3
X_4908_ _4908_/A _4908_/B VGND VGND VPWR VPWR _4909_/C sky130_fd_sc_hd__nor2_2
XTAP_TAPCELL_ROW_23_525 VGND VPWR sky130_fd_sc_hd__tapvpwrvgnd_1
XFILLER_21_541 VGND VGND VPWR VPWR sky130_fd_sc_hd__decap_3
XTAP_TAPCELL_ROW_51_867 VGND VPWR sky130_fd_sc_hd__tapvpwrvgnd_1
XFILLER_21_585 VGND VGND VPWR VPWR sky130_fd_sc_hd__decap_3
X_4839_ _4916_/A _4916_/B _4634_/Y VGND VGND VPWR VPWR _4903_/C sky130_fd_sc_hd__a21o_2
XFILLER_107_635 VGND VGND VPWR VPWR sky130_fd_sc_hd__decap_3
XFILLER_112_6 VGND VGND VPWR VPWR sky130_fd_sc_hd__decap_3
X_6509_ _6644_/A VGND VGND VPWR VPWR _6509_/Y sky130_fd_sc_hd__inv_2
XFILLER_106_134 VGND VGND VPWR VPWR sky130_fd_sc_hd__fill_2
XFILLER_107_668 VGND VGND VPWR VPWR sky130_fd_sc_hd__decap_3
XFILLER_107_679 VGND VGND VPWR VPWR sky130_fd_sc_hd__decap_3
XTAP_TAPCELL_ROW_95_1387 VGND VPWR sky130_fd_sc_hd__tapvpwrvgnd_1
XFILLER_0_401 VGND VGND VPWR VPWR sky130_fd_sc_hd__fill_2
XFILLER_20_88 VGND VGND VPWR VPWR sky130_fd_sc_hd__decap_3
XFILLER_96_15 VGND VGND VPWR VPWR sky130_fd_sc_hd__decap_3
XFILLER_0_434 VGND VGND VPWR VPWR sky130_fd_sc_hd__decap_3
XFILLER_29_20 VGND VGND VPWR VPWR sky130_fd_sc_hd__decap_3
XFILLER_0_489 VGND VGND VPWR VPWR sky130_fd_sc_hd__fill_2
XFILLER_102_351 VGND VGND VPWR VPWR sky130_fd_sc_hd__decap_3
XFILLER_88_563 VGND VGND VPWR VPWR sky130_fd_sc_hd__decap_3
XFILLER_102_395 VGND VGND VPWR VPWR sky130_fd_sc_hd__decap_3
XFILLER_48_449 VGND VGND VPWR VPWR sky130_fd_sc_hd__decap_3
XTAP_TAPCELL_ROW_59_956 VGND VPWR sky130_fd_sc_hd__tapvpwrvgnd_1
XFILLER_29_641 VGND VGND VPWR VPWR sky130_fd_sc_hd__decap_3
XFILLER_29_685 VGND VGND VPWR VPWR sky130_fd_sc_hd__decap_3
XFILLER_44_622 VGND VGND VPWR VPWR sky130_fd_sc_hd__decap_3
XFILLER_56_471 VGND VGND VPWR VPWR sky130_fd_sc_hd__decap_3
Xplace408 _3562_/A VGND VGND VPWR VPWR _4534_/S sky130_fd_sc_hd__buf_2
Xplace419 _4390_/B1 VGND VGND VPWR VPWR _3947_/S sky130_fd_sc_hd__buf_2
XTAP_TAPCELL_ROW_3_283 VGND VPWR sky130_fd_sc_hd__tapvpwrvgnd_1
XFILLER_28_195 VGND VGND VPWR VPWR sky130_fd_sc_hd__fill_1
XFILLER_43_121 VGND VGND VPWR VPWR sky130_fd_sc_hd__decap_3
XFILLER_44_666 VGND VGND VPWR VPWR sky130_fd_sc_hd__decap_3
XFILLER_45_74 VGND VGND VPWR VPWR sky130_fd_sc_hd__decap_3
XFILLER_71_441 VGND VGND VPWR VPWR sky130_fd_sc_hd__decap_3
XFILLER_71_452 VGND VGND VPWR VPWR sky130_fd_sc_hd__decap_3
XFILLER_16_368 VGND VGND VPWR VPWR sky130_fd_sc_hd__decap_3
XFILLER_43_165 VGND VGND VPWR VPWR sky130_fd_sc_hd__decap_3
XFILLER_31_327 VGND VGND VPWR VPWR sky130_fd_sc_hd__decap_3
XTAP_TAPCELL_ROW_104_1494 VGND VPWR sky130_fd_sc_hd__tapvpwrvgnd_1
XFILLER_12_563 VGND VGND VPWR VPWR sky130_fd_sc_hd__decap_3
XFILLER_8_545 VGND VGND VPWR VPWR sky130_fd_sc_hd__decap_3
XFILLER_8_578 VGND VGND VPWR VPWR sky130_fd_sc_hd__decap_3
XFILLER_8_589 VGND VGND VPWR VPWR sky130_fd_sc_hd__decap_3
XANTENNA_6 _7396_/Q VGND VGND VPWR VPWR sky130_fd_sc_hd__diode_2
XFILLER_113_638 VGND VGND VPWR VPWR sky130_fd_sc_hd__decap_3
XFILLER_106_690 VGND VGND VPWR VPWR sky130_fd_sc_hd__fill_1
XFILLER_39_405 VGND VGND VPWR VPWR sky130_fd_sc_hd__decap_3
XFILLER_79_585 VGND VGND VPWR VPWR sky130_fd_sc_hd__decap_3
XFILLER_94_500 VGND VGND VPWR VPWR sky130_fd_sc_hd__decap_3
XFILLER_39_449 VGND VGND VPWR VPWR sky130_fd_sc_hd__fill_2
XFILLER_94_533 VGND VGND VPWR VPWR sky130_fd_sc_hd__decap_3
XFILLER_54_408 VGND VGND VPWR VPWR sky130_fd_sc_hd__fill_2
XFILLER_54_419 VGND VGND VPWR VPWR sky130_fd_sc_hd__fill_1
XFILLER_66_268 VGND VGND VPWR VPWR sky130_fd_sc_hd__decap_3
XFILLER_94_566 VGND VGND VPWR VPWR sky130_fd_sc_hd__decap_3
XFILLER_35_600 VGND VGND VPWR VPWR sky130_fd_sc_hd__decap_3
XFILLER_81_205 VGND VGND VPWR VPWR sky130_fd_sc_hd__decap_3
XFILLER_19_195 VGND VGND VPWR VPWR sky130_fd_sc_hd__decap_3
XFILLER_35_644 VGND VGND VPWR VPWR sky130_fd_sc_hd__decap_3
XFILLER_62_430 VGND VGND VPWR VPWR sky130_fd_sc_hd__decap_3
X_6860_ _6959_/CLK _6860_/D VGND VGND VPWR VPWR _6860_/Q sky130_fd_sc_hd__dfxtp_2
XFILLER_35_688 VGND VGND VPWR VPWR sky130_fd_sc_hd__decap_3
XFILLER_50_625 VGND VGND VPWR VPWR sky130_fd_sc_hd__decap_3
XFILLER_62_463 VGND VGND VPWR VPWR sky130_fd_sc_hd__fill_2
X_6791_ _6959_/CLK _6791_/D VGND VGND VPWR VPWR _6791_/Q sky130_fd_sc_hd__dfxtp_2
XFILLER_50_669 VGND VGND VPWR VPWR sky130_fd_sc_hd__decap_3
XFILLER_30_371 VGND VGND VPWR VPWR sky130_fd_sc_hd__decap_3
X_7412_ _7412_/A VGND VGND VPWR VPWR _7412_/X sky130_fd_sc_hd__buf_2
X_4624_ _4624_/A _4624_/B VGND VGND VPWR VPWR _4624_/X sky130_fd_sc_hd__and2_2
XPHY_EDGE_ROW_6_Right_6 VGND VGND VPWR VPWR sky130_fd_sc_hd__decap_3
XFILLER_116_421 VGND VGND VPWR VPWR sky130_fd_sc_hd__decap_3
X_7343_ _7383_/CLK _7343_/D _6623_/Y VGND VGND VPWR VPWR _7343_/Q sky130_fd_sc_hd__dfrtp_2
X_3506_ _3544_/A _3506_/B VGND VGND VPWR VPWR _3506_/Y sky130_fd_sc_hd__nand2_2
XFILLER_104_616 VGND VGND VPWR VPWR sky130_fd_sc_hd__decap_3
X_7274_ _7406_/CLK _7274_/D _6554_/Y VGND VGND VPWR VPWR _7274_/Q sky130_fd_sc_hd__dfrtp_2
X_4486_ _4486_/A0 _7304_/Q _4505_/S VGND VGND VPWR VPWR _7336_/D sky130_fd_sc_hd__mux2_2
XFILLER_106_14 VGND VGND VPWR VPWR sky130_fd_sc_hd__decap_3
Xhold589 _6922_/Q VGND VGND VPWR VPWR _6922_/D sky130_fd_sc_hd__dlygate4sd3_1
XFILLER_106_47 VGND VGND VPWR VPWR sky130_fd_sc_hd__decap_3
XFILLER_112_660 VGND VGND VPWR VPWR sky130_fd_sc_hd__decap_3
XFILLER_66_18 VGND VGND VPWR VPWR sky130_fd_sc_hd__decap_3
XFILLER_85_511 VGND VGND VPWR VPWR sky130_fd_sc_hd__decap_3
X_3368_ _5129_/A _5294_/A _3310_/Y _3561_/B VGND VGND VPWR VPWR _3368_/Y sky130_fd_sc_hd__a211oi_4
XFILLER_111_181 VGND VGND VPWR VPWR sky130_fd_sc_hd__fill_1
XFILLER_66_29 VGND VGND VPWR VPWR sky130_fd_sc_hd__fill_1
XFILLER_85_533 VGND VGND VPWR VPWR sky130_fd_sc_hd__decap_3
XFILLER_97_393 VGND VGND VPWR VPWR sky130_fd_sc_hd__decap_3
Xhold1201 _7181_/Q VGND VGND VPWR VPWR _5298_/A0 sky130_fd_sc_hd__dlygate4sd3_1
Xhold1212 _7290_/Q VGND VGND VPWR VPWR _4581_/A sky130_fd_sc_hd__dlygate4sd3_1
Xhold1223 _7009_/Q VGND VGND VPWR VPWR _7009_/D sky130_fd_sc_hd__dlygate4sd3_1
X_5107_ _5156_/S _6985_/D _5105_/X _5106_/X VGND VGND VPWR VPWR _5107_/X sky130_fd_sc_hd__o22a_2
X_3299_ _6980_/Q _3331_/B _3324_/A VGND VGND VPWR VPWR _3328_/A sky130_fd_sc_hd__o21a_2
XFILLER_26_622 VGND VGND VPWR VPWR sky130_fd_sc_hd__decap_3
XFILLER_38_460 VGND VGND VPWR VPWR sky130_fd_sc_hd__decap_3
XFILLER_45_419 VGND VGND VPWR VPWR sky130_fd_sc_hd__decap_3
XFILLER_72_227 VGND VGND VPWR VPWR sky130_fd_sc_hd__decap_3
XFILLER_85_588 VGND VGND VPWR VPWR sky130_fd_sc_hd__decap_3
X_5038_ _5038_/A _5038_/B VGND VGND VPWR VPWR _5038_/X sky130_fd_sc_hd__xor2_2
XTAP_TAPCELL_ROW_56_926 VGND VPWR sky130_fd_sc_hd__tapvpwrvgnd_1
XFILLER_25_132 VGND VGND VPWR VPWR sky130_fd_sc_hd__decap_3
XFILLER_26_666 VGND VGND VPWR VPWR sky130_fd_sc_hd__decap_3
XTAP_TAPCELL_ROW_0_253 VGND VPWR sky130_fd_sc_hd__tapvpwrvgnd_1
XTAP_TAPCELL_ROW_0_242 VGND VPWR sky130_fd_sc_hd__tapvpwrvgnd_1
XFILLER_25_165 VGND VGND VPWR VPWR sky130_fd_sc_hd__decap_3
XFILLER_41_603 VGND VGND VPWR VPWR sky130_fd_sc_hd__decap_3
XFILLER_53_452 VGND VGND VPWR VPWR sky130_fd_sc_hd__decap_3
XFILLER_15_66 VGND VGND VPWR VPWR sky130_fd_sc_hd__decap_3
XFILLER_40_102 VGND VGND VPWR VPWR sky130_fd_sc_hd__fill_2
XFILLER_41_647 VGND VGND VPWR VPWR sky130_fd_sc_hd__decap_3
X_6989_ _7398_/CLK _6989_/D _6269_/Y VGND VGND VPWR VPWR _6989_/Q sky130_fd_sc_hd__dfrtp_2
XTAP_TAPCELL_ROW_36_683 VGND VPWR sky130_fd_sc_hd__tapvpwrvgnd_1
XFILLER_40_168 VGND VGND VPWR VPWR sky130_fd_sc_hd__fill_2
XFILLER_21_393 VGND VGND VPWR VPWR sky130_fd_sc_hd__decap_3
XTAP_TAPCELL_ROW_97_1416 VGND VPWR sky130_fd_sc_hd__tapvpwrvgnd_1
XFILLER_110_3 VGND VGND VPWR VPWR sky130_fd_sc_hd__decap_3
XFILLER_5_526 VGND VGND VPWR VPWR sky130_fd_sc_hd__decap_3
XFILLER_107_432 VGND VGND VPWR VPWR sky130_fd_sc_hd__decap_3
XFILLER_5_559 VGND VGND VPWR VPWR sky130_fd_sc_hd__fill_1
XFILLER_107_476 VGND VGND VPWR VPWR sky130_fd_sc_hd__decap_3
XTAP_TAPCELL_ROW_8_353 VGND VPWR sky130_fd_sc_hd__tapvpwrvgnd_1
XTAP_TAPCELL_ROW_8_342 VGND VPWR sky130_fd_sc_hd__tapvpwrvgnd_1
XFILLER_0_264 VGND VGND VPWR VPWR sky130_fd_sc_hd__decap_3
XFILLER_103_671 VGND VGND VPWR VPWR sky130_fd_sc_hd__fill_1
XFILLER_110_619 VGND VGND VPWR VPWR sky130_fd_sc_hd__decap_3
XFILLER_103_682 VGND VGND VPWR VPWR sky130_fd_sc_hd__decap_3
XFILLER_76_533 VGND VGND VPWR VPWR sky130_fd_sc_hd__decap_3
XFILLER_88_371 VGND VGND VPWR VPWR sky130_fd_sc_hd__decap_3
XFILLER_48_268 VGND VGND VPWR VPWR sky130_fd_sc_hd__fill_2
XFILLER_76_566 VGND VGND VPWR VPWR sky130_fd_sc_hd__decap_3
XFILLER_17_600 VGND VGND VPWR VPWR sky130_fd_sc_hd__decap_3
XFILLER_36_419 VGND VGND VPWR VPWR sky130_fd_sc_hd__fill_1
XFILLER_56_62 VGND VGND VPWR VPWR sky130_fd_sc_hd__fill_2
XFILLER_63_216 VGND VGND VPWR VPWR sky130_fd_sc_hd__decap_3
XFILLER_91_514 VGND VGND VPWR VPWR sky130_fd_sc_hd__decap_3
XFILLER_91_525 VGND VGND VPWR VPWR sky130_fd_sc_hd__decap_3
XFILLER_17_644 VGND VGND VPWR VPWR sky130_fd_sc_hd__decap_3
XFILLER_63_249 VGND VGND VPWR VPWR sky130_fd_sc_hd__decap_3
XFILLER_91_558 VGND VGND VPWR VPWR sky130_fd_sc_hd__fill_2
XTAP_TAPCELL_ROW_106_1523 VGND VPWR sky130_fd_sc_hd__tapvpwrvgnd_1
XFILLER_17_688 VGND VGND VPWR VPWR sky130_fd_sc_hd__decap_3
XFILLER_31_113 VGND VGND VPWR VPWR sky130_fd_sc_hd__fill_2
XFILLER_32_625 VGND VGND VPWR VPWR sky130_fd_sc_hd__decap_3
XFILLER_71_293 VGND VGND VPWR VPWR sky130_fd_sc_hd__decap_3
XFILLER_32_669 VGND VGND VPWR VPWR sky130_fd_sc_hd__decap_3
XFILLER_72_83 VGND VGND VPWR VPWR sky130_fd_sc_hd__fill_1
XPHY_EDGE_ROW_59_Right_59 VGND VGND VPWR VPWR sky130_fd_sc_hd__decap_3
XFILLER_12_393 VGND VGND VPWR VPWR sky130_fd_sc_hd__decap_3
XFILLER_75_6 VGND VGND VPWR VPWR sky130_fd_sc_hd__decap_3
XFILLER_8_331 VGND VGND VPWR VPWR sky130_fd_sc_hd__decap_3
XFILLER_99_603 VGND VGND VPWR VPWR sky130_fd_sc_hd__decap_3
XFILLER_113_402 VGND VGND VPWR VPWR sky130_fd_sc_hd__decap_3
X_4340_ _7223_/Q _4349_/B1 _4338_/X _4339_/X VGND VGND VPWR VPWR _4340_/X sky130_fd_sc_hd__a211o_2
XFILLER_113_435 VGND VGND VPWR VPWR sky130_fd_sc_hd__decap_3
XFILLER_4_581 VGND VGND VPWR VPWR sky130_fd_sc_hd__decap_3
XFILLER_4_592 VGND VGND VPWR VPWR sky130_fd_sc_hd__decap_3
X_4271_ _4271_/A _4271_/B _4271_/C _4270_/Y VGND VGND VPWR VPWR _4271_/X sky130_fd_sc_hd__or4b_2
XFILLER_99_647 VGND VGND VPWR VPWR sky130_fd_sc_hd__decap_3
XFILLER_113_479 VGND VGND VPWR VPWR sky130_fd_sc_hd__decap_3
XFILLER_97_91 VGND VGND VPWR VPWR sky130_fd_sc_hd__decap_3
XFILLER_100_129 VGND VGND VPWR VPWR sky130_fd_sc_hd__decap_3
XFILLER_39_213 VGND VGND VPWR VPWR sky130_fd_sc_hd__decap_3
XPHY_EDGE_ROW_68_Right_68 VGND VGND VPWR VPWR sky130_fd_sc_hd__decap_3
XFILLER_39_257 VGND VGND VPWR VPWR sky130_fd_sc_hd__decap_3
XFILLER_39_268 VGND VGND VPWR VPWR sky130_fd_sc_hd__decap_3
XFILLER_54_205 VGND VGND VPWR VPWR sky130_fd_sc_hd__fill_2
XFILLER_67_588 VGND VGND VPWR VPWR sky130_fd_sc_hd__decap_3
XFILLER_82_525 VGND VGND VPWR VPWR sky130_fd_sc_hd__decap_3
XFILLER_82_536 VGND VGND VPWR VPWR sky130_fd_sc_hd__decap_3
XFILLER_94_385 VGND VGND VPWR VPWR sky130_fd_sc_hd__fill_2
XFILLER_47_290 VGND VGND VPWR VPWR sky130_fd_sc_hd__decap_3
XFILLER_82_569 VGND VGND VPWR VPWR sky130_fd_sc_hd__decap_3
X_6912_ _6966_/CLK _6912_/D VGND VGND VPWR VPWR _6912_/Q sky130_fd_sc_hd__dfxtp_2
XFILLER_23_603 VGND VGND VPWR VPWR sky130_fd_sc_hd__decap_3
XFILLER_35_452 VGND VGND VPWR VPWR sky130_fd_sc_hd__fill_1
X_6843_ clkload9/A _6843_/D VGND VGND VPWR VPWR _6843_/Q sky130_fd_sc_hd__dfxtp_2
XFILLER_23_647 VGND VGND VPWR VPWR sky130_fd_sc_hd__decap_3
XFILLER_50_433 VGND VGND VPWR VPWR sky130_fd_sc_hd__decap_3
XTAP_TAPCELL_ROW_81_1228 VGND VPWR sky130_fd_sc_hd__tapvpwrvgnd_1
X_6774_ _6974_/CLK _6774_/D VGND VGND VPWR VPWR _6774_/Q sky130_fd_sc_hd__dfxtp_2
XTAP_TAPCELL_ROW_33_653 VGND VPWR sky130_fd_sc_hd__tapvpwrvgnd_1
XTAP_TAPCELL_ROW_33_642 VGND VPWR sky130_fd_sc_hd__tapvpwrvgnd_1
XPHY_EDGE_ROW_77_Right_77 VGND VGND VPWR VPWR sky130_fd_sc_hd__decap_3
XFILLER_50_477 VGND VGND VPWR VPWR sky130_fd_sc_hd__decap_3
X_5725_ _7368_/Q hold913/X _5735_/S VGND VGND VPWR VPWR _6712_/D sky130_fd_sc_hd__mux2_2
XTAP_TAPCELL_ROW_61_984 VGND VPWR sky130_fd_sc_hd__tapvpwrvgnd_1
X_5656_ _5656_/A _5656_/B _5656_/C VGND VGND VPWR VPWR _5665_/C sky130_fd_sc_hd__nor3_2
XFILLER_108_218 VGND VGND VPWR VPWR sky130_fd_sc_hd__decap_3
X_5587_ _5587_/A _5587_/B VGND VGND VPWR VPWR _7034_/D sky130_fd_sc_hd__and2_2
XFILLER_2_507 VGND VGND VPWR VPWR sky130_fd_sc_hd__decap_3
XFILLER_89_113 VGND VGND VPWR VPWR sky130_fd_sc_hd__decap_3
X_7326_ _7328_/CLK _7326_/D _6606_/Y VGND VGND VPWR VPWR _7326_/Q sky130_fd_sc_hd__dfrtp_2
X_7257_ _7353_/CLK _7257_/D _6537_/Y VGND VGND VPWR VPWR _7257_/Q sky130_fd_sc_hd__dfrtp_2
X_4469_ _7009_/Q _4467_/A _3332_/B _4468_/X VGND VGND VPWR VPWR _4469_/X sky130_fd_sc_hd__a31o_2
XTAP_TAPCELL_ROW_92_1357 VGND VPWR sky130_fd_sc_hd__tapvpwrvgnd_1
XTAP_TAPCELL_ROW_5_312 VGND VPWR sky130_fd_sc_hd__tapvpwrvgnd_1
XPHY_EDGE_ROW_86_Right_86 VGND VGND VPWR VPWR sky130_fd_sc_hd__decap_3
X_7188_ _7383_/CLK _7188_/D _6468_/Y VGND VGND VPWR VPWR _7188_/Q sky130_fd_sc_hd__dfrtp_2
XFILLER_100_663 VGND VGND VPWR VPWR sky130_fd_sc_hd__decap_3
XFILLER_18_408 VGND VGND VPWR VPWR sky130_fd_sc_hd__fill_1
XFILLER_58_577 VGND VGND VPWR VPWR sky130_fd_sc_hd__decap_3
XFILLER_97_190 VGND VGND VPWR VPWR sky130_fd_sc_hd__decap_3
Xhold1020 _7184_/Q VGND VGND VPWR VPWR _5290_/A0 sky130_fd_sc_hd__dlygate4sd3_1
Xhold1031 _7216_/Q VGND VGND VPWR VPWR _5225_/A sky130_fd_sc_hd__dlygate4sd3_1
Xhold1042 _7039_/Q VGND VGND VPWR VPWR _5579_/A0 sky130_fd_sc_hd__dlygate4sd3_1
XFILLER_45_205 VGND VGND VPWR VPWR sky130_fd_sc_hd__decap_3
XFILLER_85_374 VGND VGND VPWR VPWR sky130_fd_sc_hd__decap_3
Xhold1053 _7272_/Q VGND VGND VPWR VPWR _4823_/A0 sky130_fd_sc_hd__dlygate4sd3_1
Xhold1064 _7313_/Q VGND VGND VPWR VPWR _4532_/A0 sky130_fd_sc_hd__dlygate4sd3_1
Xhold1075 _7310_/Q VGND VGND VPWR VPWR _4540_/A sky130_fd_sc_hd__dlygate4sd3_1
XFILLER_26_32 VGND VGND VPWR VPWR sky130_fd_sc_hd__fill_1
XFILLER_45_249 VGND VGND VPWR VPWR sky130_fd_sc_hd__decap_3
Xhold1086 _7193_/Q VGND VGND VPWR VPWR _5274_/A0 sky130_fd_sc_hd__dlygate4sd3_1
Xhold1097 _7222_/Q VGND VGND VPWR VPWR _5213_/A sky130_fd_sc_hd__dlygate4sd3_1
XFILLER_26_463 VGND VGND VPWR VPWR sky130_fd_sc_hd__decap_3
XFILLER_13_113 VGND VGND VPWR VPWR sky130_fd_sc_hd__decap_3
XFILLER_14_625 VGND VGND VPWR VPWR sky130_fd_sc_hd__decap_3
XFILLER_53_293 VGND VGND VPWR VPWR sky130_fd_sc_hd__decap_3
XFILLER_81_591 VGND VGND VPWR VPWR sky130_fd_sc_hd__decap_3
XPHY_EDGE_ROW_95_Right_95 VGND VGND VPWR VPWR sky130_fd_sc_hd__decap_3
XFILLER_14_669 VGND VGND VPWR VPWR sky130_fd_sc_hd__decap_3
XFILLER_41_488 VGND VGND VPWR VPWR sky130_fd_sc_hd__decap_3
XTAP_TAPCELL_ROW_101_1464 VGND VPWR sky130_fd_sc_hd__tapvpwrvgnd_1
XFILLER_21_190 VGND VGND VPWR VPWR sky130_fd_sc_hd__fill_2
XFILLER_5_301 VGND VGND VPWR VPWR sky130_fd_sc_hd__decap_3
XFILLER_5_323 VGND VGND VPWR VPWR sky130_fd_sc_hd__decap_3
XFILLER_5_345 VGND VGND VPWR VPWR sky130_fd_sc_hd__fill_1
XFILLER_5_367 VGND VGND VPWR VPWR sky130_fd_sc_hd__decap_3
XPHY_EDGE_ROW_39_Left_156 VGND VGND VPWR VPWR sky130_fd_sc_hd__decap_3
XFILLER_107_284 VGND VGND VPWR VPWR sky130_fd_sc_hd__decap_3
XFILLER_96_628 VGND VGND VPWR VPWR sky130_fd_sc_hd__decap_3
XFILLER_110_427 VGND VGND VPWR VPWR sky130_fd_sc_hd__decap_3
XFILLER_1_595 VGND VGND VPWR VPWR sky130_fd_sc_hd__decap_3
XTAP_TAPCELL_ROW_112_1593 VGND VPWR sky130_fd_sc_hd__tapvpwrvgnd_1
XFILLER_49_588 VGND VGND VPWR VPWR sky130_fd_sc_hd__decap_3
XFILLER_76_363 VGND VGND VPWR VPWR sky130_fd_sc_hd__fill_1
XFILLER_29_290 VGND VGND VPWR VPWR sky130_fd_sc_hd__decap_3
XFILLER_36_227 VGND VGND VPWR VPWR sky130_fd_sc_hd__decap_3
XFILLER_64_536 VGND VGND VPWR VPWR sky130_fd_sc_hd__decap_3
XFILLER_64_569 VGND VGND VPWR VPWR sky130_fd_sc_hd__decap_3
XPHY_EDGE_ROW_48_Left_165 VGND VGND VPWR VPWR sky130_fd_sc_hd__decap_3
XFILLER_51_208 VGND VGND VPWR VPWR sky130_fd_sc_hd__decap_3
XTAP_TAPCELL_ROW_67_1061 VGND VPWR sky130_fd_sc_hd__tapvpwrvgnd_1
XTAP_TAPCELL_ROW_67_1050 VGND VPWR sky130_fd_sc_hd__tapvpwrvgnd_1
XFILLER_32_433 VGND VGND VPWR VPWR sky130_fd_sc_hd__decap_3
XFILLER_72_580 VGND VGND VPWR VPWR sky130_fd_sc_hd__decap_3
XFILLER_83_82 VGND VGND VPWR VPWR sky130_fd_sc_hd__decap_3
XFILLER_32_466 VGND VGND VPWR VPWR sky130_fd_sc_hd__fill_1
X_3840_ _6835_/Q _3886_/B1 _3852_/B1 _6840_/Q VGND VGND VPWR VPWR _3840_/X sky130_fd_sc_hd__a22o_2
XFILLER_20_628 VGND VGND VPWR VPWR sky130_fd_sc_hd__decap_3
XFILLER_32_477 VGND VGND VPWR VPWR sky130_fd_sc_hd__decap_3
X_3771_ _6910_/Q _3888_/A2 _3889_/A2 _6862_/Q VGND VGND VPWR VPWR _3771_/X sky130_fd_sc_hd__a22o_2
XTAP_TAPCELL_ROW_30_612 VGND VPWR sky130_fd_sc_hd__tapvpwrvgnd_1
XFILLER_9_662 VGND VGND VPWR VPWR sky130_fd_sc_hd__decap_3
X_6490_ _6673_/A VGND VGND VPWR VPWR _6490_/Y sky130_fd_sc_hd__inv_2
XFILLER_9_673 VGND VGND VPWR VPWR sky130_fd_sc_hd__decap_3
XPHY_EDGE_ROW_57_Left_174 VGND VGND VPWR VPWR sky130_fd_sc_hd__decap_3
XTAP_TAPCELL_ROW_78_1190 VGND VPWR sky130_fd_sc_hd__tapvpwrvgnd_1
X_7111_ _7307_/CLK _7111_/D _6391_/Y VGND VGND VPWR VPWR _7111_/Q sky130_fd_sc_hd__dfrtp_2
Xoutput469 _5656_/C VGND VGND VPWR VPWR alu_result_out[19] sky130_fd_sc_hd__clkdlybuf4s25_1
X_4323_ _7226_/Q _4331_/A2 _3975_/S _7194_/Q VGND VGND VPWR VPWR _4323_/X sky130_fd_sc_hd__a22o_2
XFILLER_113_243 VGND VGND VPWR VPWR sky130_fd_sc_hd__fill_2
XFILLER_113_254 VGND VGND VPWR VPWR sky130_fd_sc_hd__decap_3
XFILLER_59_308 VGND VGND VPWR VPWR sky130_fd_sc_hd__decap_3
XFILLER_87_606 VGND VGND VPWR VPWR sky130_fd_sc_hd__decap_3
XFILLER_87_617 VGND VGND VPWR VPWR sky130_fd_sc_hd__decap_3
X_7042_ _7362_/CLK _7042_/D _6322_/Y VGND VGND VPWR VPWR _7042_/Q sky130_fd_sc_hd__dfrtp_2
XFILLER_113_276 VGND VGND VPWR VPWR sky130_fd_sc_hd__decap_3
XFILLER_113_287 VGND VGND VPWR VPWR sky130_fd_sc_hd__decap_3
XFILLER_86_127 VGND VGND VPWR VPWR sky130_fd_sc_hd__decap_3
X_4254_ _7229_/Q _4414_/A2 _4269_/B1 _7042_/Q _4253_/X VGND VGND VPWR VPWR _4254_/X
+ sky130_fd_sc_hd__a221o_2
XFILLER_67_330 VGND VGND VPWR VPWR sky130_fd_sc_hd__decap_3
XFILLER_95_650 VGND VGND VPWR VPWR sky130_fd_sc_hd__decap_3
X_4185_ _4289_/A _5699_/S _4185_/C VGND VGND VPWR VPWR _4636_/B sky130_fd_sc_hd__and3_2
XFILLER_103_15 VGND VGND VPWR VPWR sky130_fd_sc_hd__decap_3
XFILLER_55_503 VGND VGND VPWR VPWR sky130_fd_sc_hd__fill_1
XFILLER_55_514 VGND VGND VPWR VPWR sky130_fd_sc_hd__decap_3
XFILLER_67_363 VGND VGND VPWR VPWR sky130_fd_sc_hd__fill_1
XFILLER_82_300 VGND VGND VPWR VPWR sky130_fd_sc_hd__decap_3
XFILLER_94_171 VGND VGND VPWR VPWR sky130_fd_sc_hd__decap_3
XTAP_TAPCELL_ROW_38_712 VGND VPWR sky130_fd_sc_hd__tapvpwrvgnd_1
XPHY_EDGE_ROW_66_Left_183 VGND VGND VPWR VPWR sky130_fd_sc_hd__decap_3
XFILLER_103_48 VGND VGND VPWR VPWR sky130_fd_sc_hd__decap_3
XFILLER_27_238 VGND VGND VPWR VPWR sky130_fd_sc_hd__decap_3
XFILLER_82_333 VGND VGND VPWR VPWR sky130_fd_sc_hd__decap_3
XFILLER_94_193 VGND VGND VPWR VPWR sky130_fd_sc_hd__decap_3
XFILLER_23_422 VGND VGND VPWR VPWR sky130_fd_sc_hd__decap_3
XFILLER_63_591 VGND VGND VPWR VPWR sky130_fd_sc_hd__decap_3
XFILLER_82_399 VGND VGND VPWR VPWR sky130_fd_sc_hd__decap_3
XFILLER_11_606 VGND VGND VPWR VPWR sky130_fd_sc_hd__decap_3
XFILLER_23_455 VGND VGND VPWR VPWR sky130_fd_sc_hd__fill_1
X_6826_ _6954_/CLK _6826_/D VGND VGND VPWR VPWR _6826_/Q sky130_fd_sc_hd__dfxtp_2
XFILLER_10_105 VGND VGND VPWR VPWR sky130_fd_sc_hd__decap_3
XFILLER_11_617 VGND VGND VPWR VPWR sky130_fd_sc_hd__decap_3
XFILLER_23_488 VGND VGND VPWR VPWR sky130_fd_sc_hd__decap_3
X_6757_ _6968_/CLK _6757_/D VGND VGND VPWR VPWR _6757_/Q sky130_fd_sc_hd__dfxtp_2
XFILLER_109_505 VGND VGND VPWR VPWR sky130_fd_sc_hd__decap_3
X_5708_ _7360_/Q hold954/X _5708_/S VGND VGND VPWR VPWR _6704_/D sky130_fd_sc_hd__mux2_2
XFILLER_109_538 VGND VGND VPWR VPWR sky130_fd_sc_hd__decap_3
X_6688_ _7383_/CLK _6688_/D VGND VGND VPWR VPWR _6688_/Q sky130_fd_sc_hd__dfxtp_2
XPHY_EDGE_ROW_75_Left_192 VGND VGND VPWR VPWR sky130_fd_sc_hd__decap_3
XFILLER_12_67 VGND VGND VPWR VPWR sky130_fd_sc_hd__fill_1
XFILLER_2_337 VGND VGND VPWR VPWR sky130_fd_sc_hd__decap_3
XFILLER_88_38 VGND VGND VPWR VPWR sky130_fd_sc_hd__fill_2
X_7309_ _7374_/CLK _7309_/D _6589_/Y VGND VGND VPWR VPWR _7309_/Q sky130_fd_sc_hd__dfrtp_2
XFILLER_78_628 VGND VGND VPWR VPWR sky130_fd_sc_hd__decap_3
XFILLER_104_298 VGND VGND VPWR VPWR sky130_fd_sc_hd__decap_3
XFILLER_93_609 VGND VGND VPWR VPWR sky130_fd_sc_hd__decap_3
XFILLER_85_160 VGND VGND VPWR VPWR sky130_fd_sc_hd__decap_3
XFILLER_86_672 VGND VGND VPWR VPWR sky130_fd_sc_hd__decap_3
XFILLER_18_227 VGND VGND VPWR VPWR sky130_fd_sc_hd__decap_3
XFILLER_73_333 VGND VGND VPWR VPWR sky130_fd_sc_hd__decap_3
XFILLER_85_182 VGND VGND VPWR VPWR sky130_fd_sc_hd__decap_3
XFILLER_37_86 VGND VGND VPWR VPWR sky130_fd_sc_hd__decap_3
XFILLER_61_517 VGND VGND VPWR VPWR sky130_fd_sc_hd__fill_1
XFILLER_73_355 VGND VGND VPWR VPWR sky130_fd_sc_hd__decap_3
XTAP_TAPCELL_ROW_16_439 VGND VPWR sky130_fd_sc_hd__tapvpwrvgnd_1
XFILLER_26_293 VGND VGND VPWR VPWR sky130_fd_sc_hd__decap_3
XFILLER_14_477 VGND VGND VPWR VPWR sky130_fd_sc_hd__decap_3
XFILLER_41_252 VGND VGND VPWR VPWR sky130_fd_sc_hd__decap_3
XFILLER_41_296 VGND VGND VPWR VPWR sky130_fd_sc_hd__decap_3
XFILLER_10_672 VGND VGND VPWR VPWR sky130_fd_sc_hd__decap_3
XFILLER_6_610 VGND VGND VPWR VPWR sky130_fd_sc_hd__decap_3
XFILLER_6_643 VGND VGND VPWR VPWR sky130_fd_sc_hd__fill_1
XFILLER_6_654 VGND VGND VPWR VPWR sky130_fd_sc_hd__decap_3
XFILLER_108_560 VGND VGND VPWR VPWR sky130_fd_sc_hd__decap_3
XFILLER_115_508 VGND VGND VPWR VPWR sky130_fd_sc_hd__decap_3
XFILLER_5_164 VGND VGND VPWR VPWR sky130_fd_sc_hd__decap_3
XFILLER_6_687 VGND VGND VPWR VPWR sky130_fd_sc_hd__decap_3
XTAP_TAPCELL_ROW_114_1622 VGND VPWR sky130_fd_sc_hd__tapvpwrvgnd_1
XFILLER_5_175 VGND VGND VPWR VPWR sky130_fd_sc_hd__decap_3
XFILLER_69_606 VGND VGND VPWR VPWR sky130_fd_sc_hd__decap_3
XFILLER_69_617 VGND VGND VPWR VPWR sky130_fd_sc_hd__decap_3
XFILLER_110_213 VGND VGND VPWR VPWR sky130_fd_sc_hd__fill_1
XFILLER_78_82 VGND VGND VPWR VPWR sky130_fd_sc_hd__fill_2
XFILLER_77_650 VGND VGND VPWR VPWR sky130_fd_sc_hd__decap_3
XFILLER_96_447 VGND VGND VPWR VPWR sky130_fd_sc_hd__decap_3
XFILLER_96_458 VGND VGND VPWR VPWR sky130_fd_sc_hd__decap_3
XFILLER_37_525 VGND VGND VPWR VPWR sky130_fd_sc_hd__fill_1
XFILLER_49_352 VGND VGND VPWR VPWR sky130_fd_sc_hd__decap_3
XFILLER_83_119 VGND VGND VPWR VPWR sky130_fd_sc_hd__decap_3
XFILLER_37_547 VGND VGND VPWR VPWR sky130_fd_sc_hd__decap_3
XFILLER_49_385 VGND VGND VPWR VPWR sky130_fd_sc_hd__decap_3
XFILLER_76_193 VGND VGND VPWR VPWR sky130_fd_sc_hd__decap_3
XFILLER_92_631 VGND VGND VPWR VPWR sky130_fd_sc_hd__decap_3
XFILLER_94_70 VGND VGND VPWR VPWR sky130_fd_sc_hd__decap_3
XFILLER_52_517 VGND VGND VPWR VPWR sky130_fd_sc_hd__fill_1
XFILLER_64_377 VGND VGND VPWR VPWR sky130_fd_sc_hd__decap_3
XFILLER_92_675 VGND VGND VPWR VPWR sky130_fd_sc_hd__decap_3
XFILLER_17_271 VGND VGND VPWR VPWR sky130_fd_sc_hd__fill_1
XFILLER_24_219 VGND VGND VPWR VPWR sky130_fd_sc_hd__decap_3
XFILLER_45_591 VGND VGND VPWR VPWR sky130_fd_sc_hd__decap_3
X_4941_ _4811_/C _4936_/Y _4940_/Y VGND VGND VPWR VPWR _5657_/C sky130_fd_sc_hd__a21o_2
X_4872_ _4872_/A _4872_/B VGND VGND VPWR VPWR _4872_/X sky130_fd_sc_hd__and2_2
XFILLER_32_263 VGND VGND VPWR VPWR sky130_fd_sc_hd__fill_2
XFILLER_60_561 VGND VGND VPWR VPWR sky130_fd_sc_hd__decap_3
X_6611_ _6614_/A VGND VGND VPWR VPWR _6611_/Y sky130_fd_sc_hd__inv_2
X_3823_ _6947_/Q _3903_/B1 _3883_/B1 _6959_/Q VGND VGND VPWR VPWR _3823_/X sky130_fd_sc_hd__a22o_2
XTAP_TAPCELL_ROW_43_770 VGND VPWR sky130_fd_sc_hd__tapvpwrvgnd_1
XFILLER_20_458 VGND VGND VPWR VPWR sky130_fd_sc_hd__decap_3
X_6542_ _6542_/A VGND VGND VPWR VPWR _6542_/Y sky130_fd_sc_hd__inv_2
X_3754_ _3754_/A1 _4799_/A _3753_/X VGND VGND VPWR VPWR _7397_/D sky130_fd_sc_hd__o21a_2
X_6473_ _6644_/A VGND VGND VPWR VPWR _6473_/Y sky130_fd_sc_hd__inv_2
XFILLER_106_519 VGND VGND VPWR VPWR sky130_fd_sc_hd__decap_3
XFILLER_114_563 VGND VGND VPWR VPWR sky130_fd_sc_hd__decap_3
XFILLER_101_202 VGND VGND VPWR VPWR sky130_fd_sc_hd__decap_3
XFILLER_59_116 VGND VGND VPWR VPWR sky130_fd_sc_hd__decap_3
XFILLER_87_414 VGND VGND VPWR VPWR sky130_fd_sc_hd__decap_3
X_5286_ _5286_/A0 _5139_/X _5286_/S VGND VGND VPWR VPWR _7186_/D sky130_fd_sc_hd__mux2_2
X_4306_ _7288_/Q _5157_/S _4335_/B1 _7096_/Q VGND VGND VPWR VPWR _4311_/A sky130_fd_sc_hd__a22o_2
XFILLER_99_285 VGND VGND VPWR VPWR sky130_fd_sc_hd__decap_3
XFILLER_75_609 VGND VGND VPWR VPWR sky130_fd_sc_hd__decap_3
X_7025_ _7365_/CLK _7025_/D _6305_/Y VGND VGND VPWR VPWR _7025_/Q sky130_fd_sc_hd__dfrtp_2
X_4237_ _7259_/Q _4601_/S _4236_/X VGND VGND VPWR VPWR _4237_/X sky130_fd_sc_hd__a21o_2
XFILLER_114_47 VGND VGND VPWR VPWR sky130_fd_sc_hd__decap_3
XFILLER_28_503 VGND VGND VPWR VPWR sky130_fd_sc_hd__decap_3
XFILLER_67_160 VGND VGND VPWR VPWR sky130_fd_sc_hd__decap_3
XFILLER_68_672 VGND VGND VPWR VPWR sky130_fd_sc_hd__decap_3
XFILLER_28_536 VGND VGND VPWR VPWR sky130_fd_sc_hd__decap_3
XFILLER_67_193 VGND VGND VPWR VPWR sky130_fd_sc_hd__decap_3
XFILLER_74_29 VGND VGND VPWR VPWR sky130_fd_sc_hd__decap_3
XFILLER_83_620 VGND VGND VPWR VPWR sky130_fd_sc_hd__decap_3
X_4168_ _7046_/Q _4478_/S _4394_/B _7361_/Q _4167_/X VGND VGND VPWR VPWR _4168_/X
+ sky130_fd_sc_hd__a221o_2
XFILLER_28_569 VGND VGND VPWR VPWR sky130_fd_sc_hd__decap_3
XFILLER_82_141 VGND VGND VPWR VPWR sky130_fd_sc_hd__decap_3
XFILLER_83_653 VGND VGND VPWR VPWR sky130_fd_sc_hd__decap_3
X_4099_ _7301_/Q _4491_/S _4348_/A2 _7173_/Q _4098_/X VGND VGND VPWR VPWR _4099_/X
+ sky130_fd_sc_hd__a221o_2
XFILLER_55_399 VGND VGND VPWR VPWR sky130_fd_sc_hd__decap_3
XFILLER_82_185 VGND VGND VPWR VPWR sky130_fd_sc_hd__decap_3
XFILLER_11_414 VGND VGND VPWR VPWR sky130_fd_sc_hd__fill_2
XFILLER_23_11 VGND VGND VPWR VPWR sky130_fd_sc_hd__fill_1
XFILLER_23_252 VGND VGND VPWR VPWR sky130_fd_sc_hd__fill_1
XFILLER_23_263 VGND VGND VPWR VPWR sky130_fd_sc_hd__fill_2
XFILLER_51_561 VGND VGND VPWR VPWR sky130_fd_sc_hd__decap_3
X_6809_ _6968_/CLK _6809_/D VGND VGND VPWR VPWR _6809_/Q sky130_fd_sc_hd__dfxtp_2
XTAP_TAPCELL_ROW_13_409 VGND VPWR sky130_fd_sc_hd__tapvpwrvgnd_1
XPHY_EDGE_ROW_83_Left_200 VGND VGND VPWR VPWR sky130_fd_sc_hd__decap_3
XFILLER_23_296 VGND VGND VPWR VPWR sky130_fd_sc_hd__decap_3
XFILLER_23_55 VGND VGND VPWR VPWR sky130_fd_sc_hd__fill_1
XFILLER_51_594 VGND VGND VPWR VPWR sky130_fd_sc_hd__decap_3
XFILLER_11_469 VGND VGND VPWR VPWR sky130_fd_sc_hd__fill_2
XFILLER_23_88 VGND VGND VPWR VPWR sky130_fd_sc_hd__decap_3
XFILLER_7_418 VGND VGND VPWR VPWR sky130_fd_sc_hd__decap_3
XFILLER_109_368 VGND VGND VPWR VPWR sky130_fd_sc_hd__decap_3
XFILLER_3_635 VGND VGND VPWR VPWR sky130_fd_sc_hd__decap_3
XFILLER_105_541 VGND VGND VPWR VPWR sky130_fd_sc_hd__decap_3
XFILLER_3_3 VGND VGND VPWR VPWR sky130_fd_sc_hd__decap_3
XFILLER_3_668 VGND VGND VPWR VPWR sky130_fd_sc_hd__decap_3
XFILLER_3_679 VGND VGND VPWR VPWR sky130_fd_sc_hd__decap_3
XFILLER_105_585 VGND VGND VPWR VPWR sky130_fd_sc_hd__decap_3
XFILLER_2_167 VGND VGND VPWR VPWR sky130_fd_sc_hd__decap_3
XFILLER_59_650 VGND VGND VPWR VPWR sky130_fd_sc_hd__decap_3
XFILLER_93_428 VGND VGND VPWR VPWR sky130_fd_sc_hd__decap_3
XFILLER_19_525 VGND VGND VPWR VPWR sky130_fd_sc_hd__decap_3
XFILLER_48_96 VGND VGND VPWR VPWR sky130_fd_sc_hd__fill_2
XFILLER_58_193 VGND VGND VPWR VPWR sky130_fd_sc_hd__decap_3
XFILLER_74_631 VGND VGND VPWR VPWR sky130_fd_sc_hd__decap_3
XFILLER_19_558 VGND VGND VPWR VPWR sky130_fd_sc_hd__fill_2
XFILLER_74_675 VGND VGND VPWR VPWR sky130_fd_sc_hd__decap_3
XTAP_TAPCELL_ROW_29_597 VGND VPWR sky130_fd_sc_hd__tapvpwrvgnd_1
XFILLER_27_591 VGND VGND VPWR VPWR sky130_fd_sc_hd__decap_3
XFILLER_61_369 VGND VGND VPWR VPWR sky130_fd_sc_hd__decap_3
XTAP_TAPCELL_ROW_64_1020 VGND VPWR sky130_fd_sc_hd__tapvpwrvgnd_1
XFILLER_14_274 VGND VGND VPWR VPWR sky130_fd_sc_hd__decap_3
XFILLER_42_572 VGND VGND VPWR VPWR sky130_fd_sc_hd__decap_3
XFILLER_9_24 VGND VGND VPWR VPWR sky130_fd_sc_hd__decap_3
XFILLER_14_285 VGND VGND VPWR VPWR sky130_fd_sc_hd__decap_3
XFILLER_80_61 VGND VGND VPWR VPWR sky130_fd_sc_hd__decap_3
XFILLER_10_480 VGND VGND VPWR VPWR sky130_fd_sc_hd__fill_1
Xhold908 _6706_/Q VGND VGND VPWR VPWR hold908/X sky130_fd_sc_hd__dlygate4sd3_1
Xhold919 _6714_/Q VGND VGND VPWR VPWR hold919/X sky130_fd_sc_hd__dlygate4sd3_1
X_3470_ _3468_/X _3424_/S _4289_/A _4537_/B VGND VGND VPWR VPWR _3545_/B sky130_fd_sc_hd__o2bb2a_2
XFILLER_111_500 VGND VGND VPWR VPWR sky130_fd_sc_hd__decap_3
XFILLER_111_511 VGND VGND VPWR VPWR sky130_fd_sc_hd__decap_3
XFILLER_96_211 VGND VGND VPWR VPWR sky130_fd_sc_hd__decap_3
X_5140_ _5140_/A0 _5139_/X _5157_/S VGND VGND VPWR VPWR _7250_/D sky130_fd_sc_hd__mux2_2
XFILLER_111_544 VGND VGND VPWR VPWR sky130_fd_sc_hd__decap_3
XFILLER_2_690 VGND VGND VPWR VPWR sky130_fd_sc_hd__fill_1
XFILLER_57_609 VGND VGND VPWR VPWR sky130_fd_sc_hd__decap_3
XFILLER_96_233 VGND VGND VPWR VPWR sky130_fd_sc_hd__fill_2
X_5071_ _5071_/A _5071_/B VGND VGND VPWR VPWR _5072_/C sky130_fd_sc_hd__nand2_2
XFILLER_111_588 VGND VGND VPWR VPWR sky130_fd_sc_hd__decap_3
XFILLER_96_277 VGND VGND VPWR VPWR sky130_fd_sc_hd__decap_3
XFILLER_96_288 VGND VGND VPWR VPWR sky130_fd_sc_hd__decap_3
XFILLER_49_182 VGND VGND VPWR VPWR sky130_fd_sc_hd__fill_2
XFILLER_49_193 VGND VGND VPWR VPWR sky130_fd_sc_hd__decap_3
XFILLER_65_620 VGND VGND VPWR VPWR sky130_fd_sc_hd__decap_3
XFILLER_77_480 VGND VGND VPWR VPWR sky130_fd_sc_hd__decap_3
XFILLER_37_344 VGND VGND VPWR VPWR sky130_fd_sc_hd__fill_2
XFILLER_64_152 VGND VGND VPWR VPWR sky130_fd_sc_hd__decap_3
XFILLER_65_653 VGND VGND VPWR VPWR sky130_fd_sc_hd__decap_3
XFILLER_80_601 VGND VGND VPWR VPWR sky130_fd_sc_hd__decap_3
XFILLER_92_461 VGND VGND VPWR VPWR sky130_fd_sc_hd__decap_3
XFILLER_37_377 VGND VGND VPWR VPWR sky130_fd_sc_hd__decap_3
XFILLER_37_388 VGND VGND VPWR VPWR sky130_fd_sc_hd__fill_1
XFILLER_80_634 VGND VGND VPWR VPWR sky130_fd_sc_hd__decap_3
XFILLER_52_358 VGND VGND VPWR VPWR sky130_fd_sc_hd__decap_3
XFILLER_80_645 VGND VGND VPWR VPWR sky130_fd_sc_hd__decap_3
XFILLER_80_678 VGND VGND VPWR VPWR sky130_fd_sc_hd__decap_3
X_4924_ _4920_/A _4922_/X _4923_/Y VGND VGND VPWR VPWR _4924_/X sky130_fd_sc_hd__a21o_2
XFILLER_100_27 VGND VGND VPWR VPWR sky130_fd_sc_hd__fill_1
XFILLER_33_561 VGND VGND VPWR VPWR sky130_fd_sc_hd__decap_3
XFILLER_100_38 VGND VGND VPWR VPWR sky130_fd_sc_hd__decap_3
XFILLER_20_200 VGND VGND VPWR VPWR sky130_fd_sc_hd__decap_3
XFILLER_20_211 VGND VGND VPWR VPWR sky130_fd_sc_hd__decap_3
XFILLER_33_594 VGND VGND VPWR VPWR sky130_fd_sc_hd__decap_3
XFILLER_60_391 VGND VGND VPWR VPWR sky130_fd_sc_hd__decap_3
X_4855_ _4855_/A _4855_/B _4854_/X VGND VGND VPWR VPWR _5655_/D sky130_fd_sc_hd__or3b_4
X_4786_ _4397_/Y _4795_/B _4648_/A VGND VGND VPWR VPWR _4787_/B sky130_fd_sc_hd__a21o_2
X_3806_ _6966_/Q _3921_/A2 _3903_/A2 _6954_/Q _3805_/X VGND VGND VPWR VPWR _3806_/X
+ sky130_fd_sc_hd__a221o_2
XFILLER_109_14 VGND VGND VPWR VPWR sky130_fd_sc_hd__decap_3
XFILLER_20_277 VGND VGND VPWR VPWR sky130_fd_sc_hd__decap_3
XFILLER_20_299 VGND VGND VPWR VPWR sky130_fd_sc_hd__decap_3
X_6525_ _6620_/A VGND VGND VPWR VPWR _6525_/Y sky130_fd_sc_hd__inv_2
X_3737_ _6752_/Q _3921_/A2 _3888_/B1 _6746_/Q VGND VGND VPWR VPWR _3737_/X sky130_fd_sc_hd__a22o_2
XFILLER_106_305 VGND VGND VPWR VPWR sky130_fd_sc_hd__decap_3
XFILLER_109_47 VGND VGND VPWR VPWR sky130_fd_sc_hd__decap_3
XFILLER_107_9 VGND VGND VPWR VPWR sky130_fd_sc_hd__decap_3
XFILLER_69_18 VGND VGND VPWR VPWR sky130_fd_sc_hd__fill_2
X_6456_ _6654_/A VGND VGND VPWR VPWR _6456_/Y sky130_fd_sc_hd__inv_2
X_3668_ _6943_/Q _3768_/A2 _3925_/B1 _6895_/Q VGND VGND VPWR VPWR _3668_/X sky130_fd_sc_hd__a22o_2
X_6387_ _6581_/A VGND VGND VPWR VPWR _6387_/Y sky130_fd_sc_hd__inv_2
X_5407_ _5407_/A0 _5061_/X _5425_/S VGND VGND VPWR VPWR _7130_/D sky130_fd_sc_hd__mux2_2
X_3599_ _3599_/A _3600_/A VGND VGND VPWR VPWR _4614_/C sky130_fd_sc_hd__nor2_2
XFILLER_102_522 VGND VGND VPWR VPWR sky130_fd_sc_hd__decap_3
X_5338_ _5338_/A0 _5061_/X _5354_/S VGND VGND VPWR VPWR _7162_/D sky130_fd_sc_hd__mux2_2
XFILLER_102_533 VGND VGND VPWR VPWR sky130_fd_sc_hd__decap_3
XFILLER_102_566 VGND VGND VPWR VPWR sky130_fd_sc_hd__decap_3
X_7008_ _7374_/CLK _7008_/D _6288_/Y VGND VGND VPWR VPWR _7008_/Q sky130_fd_sc_hd__dfrtp_2
XTAP_TAPCELL_ROW_89_1318 VGND VPWR sky130_fd_sc_hd__tapvpwrvgnd_1
XFILLER_56_631 VGND VGND VPWR VPWR sky130_fd_sc_hd__decap_3
XFILLER_68_491 VGND VGND VPWR VPWR sky130_fd_sc_hd__decap_3
XFILLER_75_439 VGND VGND VPWR VPWR sky130_fd_sc_hd__decap_3
XFILLER_16_506 VGND VGND VPWR VPWR sky130_fd_sc_hd__fill_2
XFILLER_56_675 VGND VGND VPWR VPWR sky130_fd_sc_hd__decap_3
XFILLER_16_517 VGND VGND VPWR VPWR sky130_fd_sc_hd__decap_3
XFILLER_16_539 VGND VGND VPWR VPWR sky130_fd_sc_hd__decap_3
XFILLER_28_388 VGND VGND VPWR VPWR sky130_fd_sc_hd__fill_2
XFILLER_43_314 VGND VGND VPWR VPWR sky130_fd_sc_hd__decap_3
XFILLER_71_612 VGND VGND VPWR VPWR sky130_fd_sc_hd__decap_3
XFILLER_71_623 VGND VGND VPWR VPWR sky130_fd_sc_hd__decap_3
XFILLER_71_656 VGND VGND VPWR VPWR sky130_fd_sc_hd__decap_3
XFILLER_24_572 VGND VGND VPWR VPWR sky130_fd_sc_hd__decap_3
XFILLER_70_177 VGND VGND VPWR VPWR sky130_fd_sc_hd__decap_3
XTAP_TAPCELL_ROW_54_898 VGND VPWR sky130_fd_sc_hd__tapvpwrvgnd_1
XTAP_TAPCELL_ROW_26_567 VGND VPWR sky130_fd_sc_hd__tapvpwrvgnd_1
XFILLER_11_222 VGND VGND VPWR VPWR sky130_fd_sc_hd__fill_2
XFILLER_51_391 VGND VGND VPWR VPWR sky130_fd_sc_hd__fill_1
XFILLER_11_277 VGND VGND VPWR VPWR sky130_fd_sc_hd__decap_3
XFILLER_11_288 VGND VGND VPWR VPWR sky130_fd_sc_hd__decap_3
XFILLER_11_299 VGND VGND VPWR VPWR sky130_fd_sc_hd__decap_3
XFILLER_109_165 VGND VGND VPWR VPWR sky130_fd_sc_hd__decap_3
XFILLER_3_443 VGND VGND VPWR VPWR sky130_fd_sc_hd__decap_3
XFILLER_3_487 VGND VGND VPWR VPWR sky130_fd_sc_hd__decap_3
XFILLER_78_200 VGND VGND VPWR VPWR sky130_fd_sc_hd__decap_3
XFILLER_105_393 VGND VGND VPWR VPWR sky130_fd_sc_hd__fill_2
XFILLER_39_609 VGND VGND VPWR VPWR sky130_fd_sc_hd__decap_3
XFILLER_59_84 VGND VGND VPWR VPWR sky130_fd_sc_hd__decap_3
XFILLER_66_417 VGND VGND VPWR VPWR sky130_fd_sc_hd__decap_3
XFILLER_115_90 VGND VGND VPWR VPWR sky130_fd_sc_hd__decap_3
XFILLER_19_311 VGND VGND VPWR VPWR sky130_fd_sc_hd__decap_3
XFILLER_47_620 VGND VGND VPWR VPWR sky130_fd_sc_hd__decap_3
XFILLER_78_288 VGND VGND VPWR VPWR sky130_fd_sc_hd__decap_3
XFILLER_93_214 VGND VGND VPWR VPWR sky130_fd_sc_hd__fill_1
XFILLER_93_225 VGND VGND VPWR VPWR sky130_fd_sc_hd__decap_3
XTAP_TAPCELL_ROW_70_1090 VGND VPWR sky130_fd_sc_hd__tapvpwrvgnd_1
XFILLER_46_141 VGND VGND VPWR VPWR sky130_fd_sc_hd__decap_3
XFILLER_47_653 VGND VGND VPWR VPWR sky130_fd_sc_hd__decap_3
XTAP_TAPCELL_ROW_109_1554 VGND VPWR sky130_fd_sc_hd__tapvpwrvgnd_1
XFILLER_34_303 VGND VGND VPWR VPWR sky130_fd_sc_hd__decap_3
XFILLER_62_601 VGND VGND VPWR VPWR sky130_fd_sc_hd__decap_3
XFILLER_62_634 VGND VGND VPWR VPWR sky130_fd_sc_hd__decap_3
XFILLER_74_472 VGND VGND VPWR VPWR sky130_fd_sc_hd__decap_3
XFILLER_74_494 VGND VGND VPWR VPWR sky130_fd_sc_hd__fill_1
XTAP_TAPCELL_ROW_109_1565 VGND VPWR sky130_fd_sc_hd__tapvpwrvgnd_1
XFILLER_34_336 VGND VGND VPWR VPWR sky130_fd_sc_hd__decap_3
XFILLER_62_645 VGND VGND VPWR VPWR sky130_fd_sc_hd__decap_3
XFILLER_15_550 VGND VGND VPWR VPWR sky130_fd_sc_hd__decap_3
XFILLER_15_561 VGND VGND VPWR VPWR sky130_fd_sc_hd__decap_3
XFILLER_61_166 VGND VGND VPWR VPWR sky130_fd_sc_hd__fill_2
XFILLER_62_678 VGND VGND VPWR VPWR sky130_fd_sc_hd__decap_3
XFILLER_15_594 VGND VGND VPWR VPWR sky130_fd_sc_hd__decap_3
XFILLER_30_531 VGND VGND VPWR VPWR sky130_fd_sc_hd__fill_1
XFILLER_30_564 VGND VGND VPWR VPWR sky130_fd_sc_hd__decap_3
X_4640_ _4938_/B _4918_/A VGND VGND VPWR VPWR _4640_/Y sky130_fd_sc_hd__nor2_2
X_6310_ _6635_/A VGND VGND VPWR VPWR _6310_/Y sky130_fd_sc_hd__inv_2
X_4571_ _4571_/A _4577_/B VGND VGND VPWR VPWR _7295_/D sky130_fd_sc_hd__and2_2
XFILLER_115_102 VGND VGND VPWR VPWR sky130_fd_sc_hd__decap_3
XFILLER_115_113 VGND VGND VPWR VPWR sky130_fd_sc_hd__decap_3
XFILLER_6_270 VGND VGND VPWR VPWR sky130_fd_sc_hd__fill_1
X_7290_ _7322_/CLK _7290_/D _6570_/Y VGND VGND VPWR VPWR _7290_/Q sky130_fd_sc_hd__dfrtp_2
Xhold705 _6873_/Q VGND VGND VPWR VPWR _6873_/D sky130_fd_sc_hd__dlygate4sd3_1
Xhold716 _6779_/Q VGND VGND VPWR VPWR _6779_/D sky130_fd_sc_hd__dlygate4sd3_1
Xhold727 _6953_/Q VGND VGND VPWR VPWR _6953_/D sky130_fd_sc_hd__dlygate4sd3_1
X_3522_ _5118_/C _4938_/A _4764_/B VGND VGND VPWR VPWR _3522_/Y sky130_fd_sc_hd__nand3_2
XFILLER_115_146 VGND VGND VPWR VPWR sky130_fd_sc_hd__decap_3
Xhold738 _6954_/Q VGND VGND VPWR VPWR _6954_/D sky130_fd_sc_hd__dlygate4sd3_1
Xhold749 _6892_/Q VGND VGND VPWR VPWR _6892_/D sky130_fd_sc_hd__dlygate4sd3_1
X_3453_ _7218_/Q _4331_/A2 _4338_/B1 _7378_/Q VGND VGND VPWR VPWR _3453_/X sky130_fd_sc_hd__a22o_2
XFILLER_103_308 VGND VGND VPWR VPWR sky130_fd_sc_hd__fill_1
XFILLER_103_319 VGND VGND VPWR VPWR sky130_fd_sc_hd__decap_3
XFILLER_69_211 VGND VGND VPWR VPWR sky130_fd_sc_hd__decap_3
XFILLER_97_520 VGND VGND VPWR VPWR sky130_fd_sc_hd__decap_3
XFILLER_111_330 VGND VGND VPWR VPWR sky130_fd_sc_hd__decap_3
XFILLER_97_553 VGND VGND VPWR VPWR sky130_fd_sc_hd__decap_3
X_3384_ _7315_/Q _3987_/S _4528_/B _7283_/Q VGND VGND VPWR VPWR _3384_/X sky130_fd_sc_hd__a22o_2
XFILLER_111_341 VGND VGND VPWR VPWR sky130_fd_sc_hd__decap_3
XFILLER_69_266 VGND VGND VPWR VPWR sky130_fd_sc_hd__decap_3
XFILLER_97_564 VGND VGND VPWR VPWR sky130_fd_sc_hd__decap_3
XFILLER_111_396 VGND VGND VPWR VPWR sky130_fd_sc_hd__decap_3
XFILLER_38_631 VGND VGND VPWR VPWR sky130_fd_sc_hd__decap_3
XFILLER_84_225 VGND VGND VPWR VPWR sky130_fd_sc_hd__fill_1
XFILLER_84_236 VGND VGND VPWR VPWR sky130_fd_sc_hd__fill_2
XFILLER_97_597 VGND VGND VPWR VPWR sky130_fd_sc_hd__decap_3
X_5054_ _5054_/A VGND VGND VPWR VPWR _5054_/Y sky130_fd_sc_hd__inv_2
XFILLER_38_675 VGND VGND VPWR VPWR sky130_fd_sc_hd__decap_3
XFILLER_53_612 VGND VGND VPWR VPWR sky130_fd_sc_hd__decap_3
XFILLER_53_623 VGND VGND VPWR VPWR sky130_fd_sc_hd__decap_3
XFILLER_65_461 VGND VGND VPWR VPWR sky130_fd_sc_hd__decap_3
XFILLER_111_15 VGND VGND VPWR VPWR sky130_fd_sc_hd__decap_3
XFILLER_25_358 VGND VGND VPWR VPWR sky130_fd_sc_hd__decap_3
XFILLER_52_133 VGND VGND VPWR VPWR sky130_fd_sc_hd__decap_3
XFILLER_53_656 VGND VGND VPWR VPWR sky130_fd_sc_hd__decap_3
XFILLER_65_494 VGND VGND VPWR VPWR sky130_fd_sc_hd__fill_1
XFILLER_92_280 VGND VGND VPWR VPWR sky130_fd_sc_hd__fill_2
XTAP_TAPCELL_ROW_84_1259 VGND VPWR sky130_fd_sc_hd__tapvpwrvgnd_1
XFILLER_111_48 VGND VGND VPWR VPWR sky130_fd_sc_hd__decap_3
XFILLER_40_328 VGND VGND VPWR VPWR sky130_fd_sc_hd__decap_3
X_4907_ _4948_/A _4888_/B _4903_/X _4906_/X VGND VGND VPWR VPWR _4907_/Y sky130_fd_sc_hd__o31ai_4
XTAP_TAPCELL_ROW_23_526 VGND VPWR sky130_fd_sc_hd__tapvpwrvgnd_1
XFILLER_21_553 VGND VGND VPWR VPWR sky130_fd_sc_hd__decap_3
XFILLER_21_564 VGND VGND VPWR VPWR sky130_fd_sc_hd__decap_3
XTAP_TAPCELL_ROW_51_868 VGND VPWR sky130_fd_sc_hd__tapvpwrvgnd_1
XFILLER_21_597 VGND VGND VPWR VPWR sky130_fd_sc_hd__decap_3
XFILLER_107_603 VGND VGND VPWR VPWR sky130_fd_sc_hd__decap_3
X_4769_ _4969_/B _4741_/X _4761_/Y _4768_/Y VGND VGND VPWR VPWR _5663_/A sky130_fd_sc_hd__a31o_2
XFILLER_106_102 VGND VGND VPWR VPWR sky130_fd_sc_hd__decap_3
XFILLER_107_647 VGND VGND VPWR VPWR sky130_fd_sc_hd__decap_3
XFILLER_4_207 VGND VGND VPWR VPWR sky130_fd_sc_hd__fill_2
XFILLER_4_229 VGND VGND VPWR VPWR sky130_fd_sc_hd__decap_3
X_6508_ _6644_/A VGND VGND VPWR VPWR _6508_/Y sky130_fd_sc_hd__inv_2
XFILLER_105_6 VGND VGND VPWR VPWR sky130_fd_sc_hd__decap_3
X_6439_ _6626_/A VGND VGND VPWR VPWR _6439_/Y sky130_fd_sc_hd__inv_2
XTAP_TAPCELL_ROW_95_1388 VGND VPWR sky130_fd_sc_hd__tapvpwrvgnd_1
XFILLER_106_168 VGND VGND VPWR VPWR sky130_fd_sc_hd__decap_3
XFILLER_0_424 VGND VGND VPWR VPWR sky130_fd_sc_hd__fill_1
XFILLER_114_190 VGND VGND VPWR VPWR sky130_fd_sc_hd__decap_3
XFILLER_88_531 VGND VGND VPWR VPWR sky130_fd_sc_hd__fill_1
XFILLER_88_542 VGND VGND VPWR VPWR sky130_fd_sc_hd__decap_3
XFILLER_0_457 VGND VGND VPWR VPWR sky130_fd_sc_hd__decap_3
XFILLER_102_363 VGND VGND VPWR VPWR sky130_fd_sc_hd__fill_1
XFILLER_29_43 VGND VGND VPWR VPWR sky130_fd_sc_hd__fill_2
XFILLER_88_575 VGND VGND VPWR VPWR sky130_fd_sc_hd__decap_3
XFILLER_29_54 VGND VGND VPWR VPWR sky130_fd_sc_hd__fill_2
XFILLER_29_620 VGND VGND VPWR VPWR sky130_fd_sc_hd__decap_3
XFILLER_75_225 VGND VGND VPWR VPWR sky130_fd_sc_hd__decap_3
XFILLER_28_141 VGND VGND VPWR VPWR sky130_fd_sc_hd__decap_3
XFILLER_29_653 VGND VGND VPWR VPWR sky130_fd_sc_hd__decap_3
XFILLER_56_450 VGND VGND VPWR VPWR sky130_fd_sc_hd__decap_3
XTAP_TAPCELL_ROW_59_957 VGND VPWR sky130_fd_sc_hd__tapvpwrvgnd_1
XFILLER_28_174 VGND VGND VPWR VPWR sky130_fd_sc_hd__decap_3
XFILLER_44_601 VGND VGND VPWR VPWR sky130_fd_sc_hd__decap_3
XFILLER_56_483 VGND VGND VPWR VPWR sky130_fd_sc_hd__decap_3
XFILLER_90_206 VGND VGND VPWR VPWR sky130_fd_sc_hd__decap_3
Xplace409 _4437_/B1 VGND VGND VPWR VPWR _4406_/A2 sky130_fd_sc_hd__buf_2
XTAP_TAPCELL_ROW_3_284 VGND VPWR sky130_fd_sc_hd__tapvpwrvgnd_1
XPHY_EDGE_ROW_11_Left_128 VGND VGND VPWR VPWR sky130_fd_sc_hd__decap_3
XFILLER_16_358 VGND VGND VPWR VPWR sky130_fd_sc_hd__decap_3
XFILLER_44_634 VGND VGND VPWR VPWR sky130_fd_sc_hd__decap_3
XFILLER_44_645 VGND VGND VPWR VPWR sky130_fd_sc_hd__decap_3
XFILLER_45_53 VGND VGND VPWR VPWR sky130_fd_sc_hd__decap_3
XFILLER_44_678 VGND VGND VPWR VPWR sky130_fd_sc_hd__decap_3
XFILLER_71_497 VGND VGND VPWR VPWR sky130_fd_sc_hd__decap_3
XFILLER_101_92 VGND VGND VPWR VPWR sky130_fd_sc_hd__decap_3
XFILLER_12_542 VGND VGND VPWR VPWR sky130_fd_sc_hd__decap_3
XFILLER_61_30 VGND VGND VPWR VPWR sky130_fd_sc_hd__fill_1
XTAP_TAPCELL_ROW_104_1495 VGND VPWR sky130_fd_sc_hd__tapvpwrvgnd_1
XFILLER_12_575 VGND VGND VPWR VPWR sky130_fd_sc_hd__decap_3
XFILLER_8_557 VGND VGND VPWR VPWR sky130_fd_sc_hd__decap_3
XANTENNA_7 _5177_/B VGND VGND VPWR VPWR sky130_fd_sc_hd__diode_2
XFILLER_6_47 VGND VGND VPWR VPWR sky130_fd_sc_hd__fill_1
XPHY_EDGE_ROW_20_Left_137 VGND VGND VPWR VPWR sky130_fd_sc_hd__decap_3
XFILLER_113_606 VGND VGND VPWR VPWR sky130_fd_sc_hd__decap_3
XFILLER_113_617 VGND VGND VPWR VPWR sky130_fd_sc_hd__decap_3
XFILLER_98_317 VGND VGND VPWR VPWR sky130_fd_sc_hd__decap_3
XFILLER_112_149 VGND VGND VPWR VPWR sky130_fd_sc_hd__decap_3
XFILLER_3_273 VGND VGND VPWR VPWR sky130_fd_sc_hd__fill_2
XFILLER_79_542 VGND VGND VPWR VPWR sky130_fd_sc_hd__decap_3
XFILLER_79_564 VGND VGND VPWR VPWR sky130_fd_sc_hd__decap_3
XFILLER_66_236 VGND VGND VPWR VPWR sky130_fd_sc_hd__fill_2
XFILLER_79_597 VGND VGND VPWR VPWR sky130_fd_sc_hd__decap_3
XFILLER_86_82 VGND VGND VPWR VPWR sky130_fd_sc_hd__fill_2
XFILLER_94_523 VGND VGND VPWR VPWR sky130_fd_sc_hd__decap_3
XFILLER_94_545 VGND VGND VPWR VPWR sky130_fd_sc_hd__decap_3
XFILLER_94_578 VGND VGND VPWR VPWR sky130_fd_sc_hd__decap_3
XFILLER_35_612 VGND VGND VPWR VPWR sky130_fd_sc_hd__decap_3
XFILLER_35_623 VGND VGND VPWR VPWR sky130_fd_sc_hd__decap_3
XFILLER_81_228 VGND VGND VPWR VPWR sky130_fd_sc_hd__decap_3
XFILLER_94_589 VGND VGND VPWR VPWR sky130_fd_sc_hd__decap_3
XFILLER_34_122 VGND VGND VPWR VPWR sky130_fd_sc_hd__fill_1
XFILLER_35_656 VGND VGND VPWR VPWR sky130_fd_sc_hd__decap_3
XFILLER_62_442 VGND VGND VPWR VPWR sky130_fd_sc_hd__decap_3
XFILLER_74_280 VGND VGND VPWR VPWR sky130_fd_sc_hd__decap_3
XFILLER_50_604 VGND VGND VPWR VPWR sky130_fd_sc_hd__decap_3
X_6790_ _6959_/CLK _6790_/D VGND VGND VPWR VPWR _6790_/Q sky130_fd_sc_hd__dfxtp_2
XFILLER_50_637 VGND VGND VPWR VPWR sky130_fd_sc_hd__decap_3
XFILLER_50_648 VGND VGND VPWR VPWR sky130_fd_sc_hd__decap_3
XFILLER_62_497 VGND VGND VPWR VPWR sky130_fd_sc_hd__fill_1
XFILLER_30_361 VGND VGND VPWR VPWR sky130_fd_sc_hd__decap_3
X_4623_ _4330_/B _4622_/X _5057_/B VGND VGND VPWR VPWR _4624_/A sky130_fd_sc_hd__o21ba_2
XFILLER_116_411 VGND VGND VPWR VPWR sky130_fd_sc_hd__decap_3
X_7342_ _7374_/CLK _7342_/D _6622_/Y VGND VGND VPWR VPWR _7342_/Q sky130_fd_sc_hd__dfrtp_2
X_4554_ _4554_/A _4563_/B VGND VGND VPWR VPWR _7303_/D sky130_fd_sc_hd__and2_2
XFILLER_116_433 VGND VGND VPWR VPWR sky130_fd_sc_hd__decap_3
X_7273_ _7405_/CLK _7273_/D _6553_/Y VGND VGND VPWR VPWR _7273_/Q sky130_fd_sc_hd__dfrtp_2
X_3505_ _3505_/A _3505_/B VGND VGND VPWR VPWR _3505_/X sky130_fd_sc_hd__or2_4
XFILLER_104_628 VGND VGND VPWR VPWR sky130_fd_sc_hd__decap_3
XFILLER_116_466 VGND VGND VPWR VPWR sky130_fd_sc_hd__fill_2
XFILLER_116_477 VGND VGND VPWR VPWR sky130_fd_sc_hd__decap_3
XFILLER_116_499 VGND VGND VPWR VPWR sky130_fd_sc_hd__decap_3
XFILLER_103_116 VGND VGND VPWR VPWR sky130_fd_sc_hd__decap_3
XFILLER_106_26 VGND VGND VPWR VPWR sky130_fd_sc_hd__fill_2
XFILLER_106_59 VGND VGND VPWR VPWR sky130_fd_sc_hd__decap_3
XFILLER_112_672 VGND VGND VPWR VPWR sky130_fd_sc_hd__decap_3
XFILLER_85_501 VGND VGND VPWR VPWR sky130_fd_sc_hd__decap_3
XFILLER_57_203 VGND VGND VPWR VPWR sky130_fd_sc_hd__fill_2
Xhold1202 _7161_/Q VGND VGND VPWR VPWR _5340_/A0 sky130_fd_sc_hd__dlygate4sd3_1
Xhold1213 _7143_/Q VGND VGND VPWR VPWR _5379_/A0 sky130_fd_sc_hd__dlygate4sd3_1
Xhold1224 _7142_/Q VGND VGND VPWR VPWR _5381_/A0 sky130_fd_sc_hd__dlygate4sd3_1
X_5106_ _6985_/Q _5068_/C _5593_/B VGND VGND VPWR VPWR _5106_/X sky130_fd_sc_hd__o21a_2
XFILLER_57_258 VGND VGND VPWR VPWR sky130_fd_sc_hd__fill_1
XFILLER_85_545 VGND VGND VPWR VPWR sky130_fd_sc_hd__decap_3
XFILLER_85_567 VGND VGND VPWR VPWR sky130_fd_sc_hd__decap_3
X_5037_ _6988_/Q _5045_/B VGND VGND VPWR VPWR _5038_/B sky130_fd_sc_hd__nand2_2
XFILLER_26_601 VGND VGND VPWR VPWR sky130_fd_sc_hd__decap_3
XFILLER_38_483 VGND VGND VPWR VPWR sky130_fd_sc_hd__decap_3
XFILLER_72_206 VGND VGND VPWR VPWR sky130_fd_sc_hd__decap_3
XTAP_TAPCELL_ROW_56_927 VGND VPWR sky130_fd_sc_hd__tapvpwrvgnd_1
XFILLER_25_100 VGND VGND VPWR VPWR sky130_fd_sc_hd__fill_1
XFILLER_26_634 VGND VGND VPWR VPWR sky130_fd_sc_hd__decap_3
XFILLER_26_645 VGND VGND VPWR VPWR sky130_fd_sc_hd__decap_3
XFILLER_72_239 VGND VGND VPWR VPWR sky130_fd_sc_hd__decap_3
XFILLER_82_29 VGND VGND VPWR VPWR sky130_fd_sc_hd__decap_3
XTAP_TAPCELL_ROW_0_254 VGND VPWR sky130_fd_sc_hd__tapvpwrvgnd_1
XTAP_TAPCELL_ROW_0_243 VGND VPWR sky130_fd_sc_hd__tapvpwrvgnd_1
XFILLER_25_144 VGND VGND VPWR VPWR sky130_fd_sc_hd__decap_3
XFILLER_26_678 VGND VGND VPWR VPWR sky130_fd_sc_hd__decap_3
XFILLER_41_615 VGND VGND VPWR VPWR sky130_fd_sc_hd__fill_1
XFILLER_53_464 VGND VGND VPWR VPWR sky130_fd_sc_hd__decap_3
XFILLER_13_317 VGND VGND VPWR VPWR sky130_fd_sc_hd__decap_3
XFILLER_25_177 VGND VGND VPWR VPWR sky130_fd_sc_hd__fill_2
XFILLER_41_626 VGND VGND VPWR VPWR sky130_fd_sc_hd__decap_3
XFILLER_80_283 VGND VGND VPWR VPWR sky130_fd_sc_hd__decap_3
X_6988_ _7398_/CLK _6988_/D _6268_/Y VGND VGND VPWR VPWR _6988_/Q sky130_fd_sc_hd__dfrtp_2
XTAP_TAPCELL_ROW_36_684 VGND VPWR sky130_fd_sc_hd__tapvpwrvgnd_1
XFILLER_40_158 VGND VGND VPWR VPWR sky130_fd_sc_hd__fill_2
XFILLER_41_659 VGND VGND VPWR VPWR sky130_fd_sc_hd__decap_3
XFILLER_21_383 VGND VGND VPWR VPWR sky130_fd_sc_hd__decap_3
XFILLER_5_505 VGND VGND VPWR VPWR sky130_fd_sc_hd__decap_3
XTAP_TAPCELL_ROW_97_1417 VGND VPWR sky130_fd_sc_hd__tapvpwrvgnd_1
XFILLER_5_538 VGND VGND VPWR VPWR sky130_fd_sc_hd__decap_3
XFILLER_107_444 VGND VGND VPWR VPWR sky130_fd_sc_hd__decap_3
XFILLER_107_455 VGND VGND VPWR VPWR sky130_fd_sc_hd__decap_3
XFILLER_103_3 VGND VGND VPWR VPWR sky130_fd_sc_hd__decap_3
XFILLER_107_488 VGND VGND VPWR VPWR sky130_fd_sc_hd__decap_3
XTAP_TAPCELL_ROW_8_343 VGND VPWR sky130_fd_sc_hd__tapvpwrvgnd_1
XFILLER_103_650 VGND VGND VPWR VPWR sky130_fd_sc_hd__decap_3
XFILLER_95_309 VGND VGND VPWR VPWR sky130_fd_sc_hd__decap_3
XFILLER_0_287 VGND VGND VPWR VPWR sky130_fd_sc_hd__decap_3
XFILLER_48_203 VGND VGND VPWR VPWR sky130_fd_sc_hd__decap_3
XFILLER_48_225 VGND VGND VPWR VPWR sky130_fd_sc_hd__decap_3
XFILLER_88_383 VGND VGND VPWR VPWR sky130_fd_sc_hd__fill_1
XFILLER_76_545 VGND VGND VPWR VPWR sky130_fd_sc_hd__decap_3
XFILLER_76_578 VGND VGND VPWR VPWR sky130_fd_sc_hd__decap_3
XFILLER_17_612 VGND VGND VPWR VPWR sky130_fd_sc_hd__decap_3
XFILLER_29_472 VGND VGND VPWR VPWR sky130_fd_sc_hd__decap_3
XFILLER_63_228 VGND VGND VPWR VPWR sky130_fd_sc_hd__decap_3
XFILLER_76_589 VGND VGND VPWR VPWR sky130_fd_sc_hd__decap_3
XFILLER_91_537 VGND VGND VPWR VPWR sky130_fd_sc_hd__decap_3
XFILLER_17_623 VGND VGND VPWR VPWR sky130_fd_sc_hd__decap_3
XFILLER_17_656 VGND VGND VPWR VPWR sky130_fd_sc_hd__decap_3
XFILLER_56_291 VGND VGND VPWR VPWR sky130_fd_sc_hd__decap_3
XFILLER_56_85 VGND VGND VPWR VPWR sky130_fd_sc_hd__decap_3
XTAP_TAPCELL_ROW_106_1524 VGND VPWR sky130_fd_sc_hd__tapvpwrvgnd_1
XFILLER_32_604 VGND VGND VPWR VPWR sky130_fd_sc_hd__decap_3
XFILLER_112_80 VGND VGND VPWR VPWR sky130_fd_sc_hd__decap_3
XFILLER_32_637 VGND VGND VPWR VPWR sky130_fd_sc_hd__decap_3
XFILLER_32_648 VGND VGND VPWR VPWR sky130_fd_sc_hd__decap_3
XFILLER_31_147 VGND VGND VPWR VPWR sky130_fd_sc_hd__fill_1
XFILLER_12_361 VGND VGND VPWR VPWR sky130_fd_sc_hd__decap_3
XFILLER_40_681 VGND VGND VPWR VPWR sky130_fd_sc_hd__decap_3
XFILLER_8_321 VGND VGND VPWR VPWR sky130_fd_sc_hd__decap_3
XFILLER_68_6 VGND VGND VPWR VPWR sky130_fd_sc_hd__decap_3
XFILLER_8_365 VGND VGND VPWR VPWR sky130_fd_sc_hd__decap_3
XFILLER_8_387 VGND VGND VPWR VPWR sky130_fd_sc_hd__decap_3
XFILLER_113_414 VGND VGND VPWR VPWR sky130_fd_sc_hd__decap_3
XFILLER_4_560 VGND VGND VPWR VPWR sky130_fd_sc_hd__decap_3
XFILLER_99_626 VGND VGND VPWR VPWR sky130_fd_sc_hd__decap_3
XFILLER_99_615 VGND VGND VPWR VPWR sky130_fd_sc_hd__fill_1
XFILLER_113_447 VGND VGND VPWR VPWR sky130_fd_sc_hd__fill_1
X_4270_ _7358_/Q _4312_/B VGND VGND VPWR VPWR _4270_/Y sky130_fd_sc_hd__nand2_2
XFILLER_99_659 VGND VGND VPWR VPWR sky130_fd_sc_hd__decap_3
XFILLER_101_609 VGND VGND VPWR VPWR sky130_fd_sc_hd__decap_3
XFILLER_113_458 VGND VGND VPWR VPWR sky130_fd_sc_hd__decap_3
XFILLER_86_309 VGND VGND VPWR VPWR sky130_fd_sc_hd__decap_3
XFILLER_98_158 VGND VGND VPWR VPWR sky130_fd_sc_hd__decap_3
XFILLER_97_70 VGND VGND VPWR VPWR sky130_fd_sc_hd__decap_3
XFILLER_39_236 VGND VGND VPWR VPWR sky130_fd_sc_hd__decap_3
XFILLER_67_567 VGND VGND VPWR VPWR sky130_fd_sc_hd__decap_3
XFILLER_94_375 VGND VGND VPWR VPWR sky130_fd_sc_hd__decap_3
XFILLER_82_548 VGND VGND VPWR VPWR sky130_fd_sc_hd__decap_3
X_6911_ _6974_/CLK _6911_/D VGND VGND VPWR VPWR _6911_/Q sky130_fd_sc_hd__dfxtp_2
XFILLER_23_615 VGND VGND VPWR VPWR sky130_fd_sc_hd__fill_1
XFILLER_35_464 VGND VGND VPWR VPWR sky130_fd_sc_hd__decap_3
X_6842_ clkload9/A _6842_/D VGND VGND VPWR VPWR _6842_/Q sky130_fd_sc_hd__dfxtp_2
XFILLER_23_626 VGND VGND VPWR VPWR sky130_fd_sc_hd__decap_3
XFILLER_35_497 VGND VGND VPWR VPWR sky130_fd_sc_hd__decap_3
XFILLER_62_261 VGND VGND VPWR VPWR sky130_fd_sc_hd__decap_3
XFILLER_90_581 VGND VGND VPWR VPWR sky130_fd_sc_hd__decap_3
XFILLER_90_592 VGND VGND VPWR VPWR sky130_fd_sc_hd__decap_3
XTAP_TAPCELL_ROW_81_1229 VGND VPWR sky130_fd_sc_hd__tapvpwrvgnd_1
XTAP_TAPCELL_ROW_81_1218 VGND VPWR sky130_fd_sc_hd__tapvpwrvgnd_1
XFILLER_23_659 VGND VGND VPWR VPWR sky130_fd_sc_hd__decap_3
X_6773_ clkload7/A _6773_/D VGND VGND VPWR VPWR _6773_/Q sky130_fd_sc_hd__dfxtp_2
X_3985_ _7348_/Q _4526_/A0 _3987_/S VGND VGND VPWR VPWR _7348_/D sky130_fd_sc_hd__mux2_2
XTAP_TAPCELL_ROW_33_643 VGND VPWR sky130_fd_sc_hd__tapvpwrvgnd_1
XFILLER_10_309 VGND VGND VPWR VPWR sky130_fd_sc_hd__decap_3
XFILLER_50_489 VGND VGND VPWR VPWR sky130_fd_sc_hd__fill_1
XTAP_TAPCELL_ROW_61_985 VGND VPWR sky130_fd_sc_hd__tapvpwrvgnd_1
X_5655_ _5655_/A _5655_/B _5655_/C _5655_/D VGND VGND VPWR VPWR _5665_/B sky130_fd_sc_hd__nor4_2
X_4606_ _5666_/A _5633_/B VGND VGND VPWR VPWR _4606_/Y sky130_fd_sc_hd__nor2_2
X_7325_ _7392_/CLK _7325_/D _6605_/Y VGND VGND VPWR VPWR _7325_/Q sky130_fd_sc_hd__dfrtp_2
X_5586_ hold958/X _5595_/B _5118_/X VGND VGND VPWR VPWR _7035_/D sky130_fd_sc_hd__o21a_2
XFILLER_104_403 VGND VGND VPWR VPWR sky130_fd_sc_hd__decap_3
XFILLER_116_241 VGND VGND VPWR VPWR sky130_fd_sc_hd__decap_3
XFILLER_2_519 VGND VGND VPWR VPWR sky130_fd_sc_hd__decap_3
XFILLER_89_103 VGND VGND VPWR VPWR sky130_fd_sc_hd__decap_3
X_4537_ _5118_/A _4537_/B _4537_/C VGND VGND VPWR VPWR _4591_/B sky130_fd_sc_hd__or3_2
XFILLER_89_125 VGND VGND VPWR VPWR sky130_fd_sc_hd__decap_3
X_7256_ _7353_/CLK _7256_/D _6536_/Y VGND VGND VPWR VPWR _7256_/Q sky130_fd_sc_hd__dfrtp_2
X_4468_ _7009_/Q _5152_/B _5595_/B VGND VGND VPWR VPWR _4468_/X sky130_fd_sc_hd__o21a_2
XTAP_TAPCELL_ROW_92_1358 VGND VPWR sky130_fd_sc_hd__tapvpwrvgnd_1
XFILLER_104_469 VGND VGND VPWR VPWR sky130_fd_sc_hd__decap_3
XFILLER_89_169 VGND VGND VPWR VPWR sky130_fd_sc_hd__fill_1
X_7187_ _7350_/CLK _7187_/D _6467_/Y VGND VGND VPWR VPWR _7187_/Q sky130_fd_sc_hd__dfrtp_2
X_3419_ _7123_/Q _4351_/B1 _3413_/X _3418_/X VGND VGND VPWR VPWR _3419_/Y sky130_fd_sc_hd__a211oi_2
XTAP_TAPCELL_ROW_5_313 VGND VPWR sky130_fd_sc_hd__tapvpwrvgnd_1
XFILLER_112_480 VGND VGND VPWR VPWR sky130_fd_sc_hd__decap_3
X_4399_ _7370_/Q _4406_/A2 _4398_/X _4429_/C1 VGND VGND VPWR VPWR _4399_/X sky130_fd_sc_hd__a211o_2
XFILLER_98_681 VGND VGND VPWR VPWR sky130_fd_sc_hd__decap_3
XFILLER_100_631 VGND VGND VPWR VPWR sky130_fd_sc_hd__decap_3
Xhold1010 _7257_/Q VGND VGND VPWR VPWR _5080_/A0 sky130_fd_sc_hd__dlygate4sd3_1
Xhold1021 _7037_/Q VGND VGND VPWR VPWR _5583_/A0 sky130_fd_sc_hd__dlygate4sd3_1
Xhold1032 _7385_/Q VGND VGND VPWR VPWR _3864_/A0 sky130_fd_sc_hd__dlygate4sd3_1
XFILLER_100_675 VGND VGND VPWR VPWR sky130_fd_sc_hd__decap_3
XFILLER_58_589 VGND VGND VPWR VPWR sky130_fd_sc_hd__decap_3
Xhold1043 _7209_/Q VGND VGND VPWR VPWR _5241_/A0 sky130_fd_sc_hd__dlygate4sd3_1
Xhold1054 _7200_/Q VGND VGND VPWR VPWR _5260_/A0 sky130_fd_sc_hd__dlygate4sd3_1
Xhold1065 _4532_/X VGND VGND VPWR VPWR _7313_/D sky130_fd_sc_hd__dlygate4sd3_1
Xhold1076 _7312_/Q VGND VGND VPWR VPWR _4534_/A0 sky130_fd_sc_hd__dlygate4sd3_1
XFILLER_38_291 VGND VGND VPWR VPWR sky130_fd_sc_hd__decap_3
XFILLER_45_228 VGND VGND VPWR VPWR sky130_fd_sc_hd__decap_3
XFILLER_73_559 VGND VGND VPWR VPWR sky130_fd_sc_hd__fill_1
Xhold1087 _7308_/Q VGND VGND VPWR VPWR _4544_/A sky130_fd_sc_hd__dlygate4sd3_1
Xhold1098 _7236_/Q VGND VGND VPWR VPWR _5184_/A sky130_fd_sc_hd__dlygate4sd3_1
XFILLER_14_604 VGND VGND VPWR VPWR sky130_fd_sc_hd__decap_3
XFILLER_26_442 VGND VGND VPWR VPWR sky130_fd_sc_hd__decap_3
XFILLER_14_637 VGND VGND VPWR VPWR sky130_fd_sc_hd__decap_3
XFILLER_14_648 VGND VGND VPWR VPWR sky130_fd_sc_hd__decap_3
XFILLER_26_475 VGND VGND VPWR VPWR sky130_fd_sc_hd__fill_1
XFILLER_26_77 VGND VGND VPWR VPWR sky130_fd_sc_hd__decap_3
XFILLER_53_261 VGND VGND VPWR VPWR sky130_fd_sc_hd__decap_3
XFILLER_81_570 VGND VGND VPWR VPWR sky130_fd_sc_hd__decap_3
XFILLER_41_467 VGND VGND VPWR VPWR sky130_fd_sc_hd__decap_3
XFILLER_13_169 VGND VGND VPWR VPWR sky130_fd_sc_hd__decap_3
XTAP_TAPCELL_ROW_101_1465 VGND VPWR sky130_fd_sc_hd__tapvpwrvgnd_1
XFILLER_22_681 VGND VGND VPWR VPWR sky130_fd_sc_hd__decap_3
XFILLER_5_335 VGND VGND VPWR VPWR sky130_fd_sc_hd__fill_1
XFILLER_110_406 VGND VGND VPWR VPWR sky130_fd_sc_hd__fill_2
XFILLER_1_541 VGND VGND VPWR VPWR sky130_fd_sc_hd__decap_3
XFILLER_3_15 VGND VGND VPWR VPWR sky130_fd_sc_hd__decap_3
XFILLER_96_607 VGND VGND VPWR VPWR sky130_fd_sc_hd__decap_3
XFILLER_107_80 VGND VGND VPWR VPWR sky130_fd_sc_hd__decap_3
XFILLER_110_417 VGND VGND VPWR VPWR sky130_fd_sc_hd__decap_3
XFILLER_110_439 VGND VGND VPWR VPWR sky130_fd_sc_hd__decap_3
XFILLER_1_574 VGND VGND VPWR VPWR sky130_fd_sc_hd__decap_3
XTAP_TAPCELL_ROW_112_1594 VGND VPWR sky130_fd_sc_hd__tapvpwrvgnd_1
XFILLER_103_480 VGND VGND VPWR VPWR sky130_fd_sc_hd__decap_3
XFILLER_49_567 VGND VGND VPWR VPWR sky130_fd_sc_hd__decap_3
XFILLER_36_206 VGND VGND VPWR VPWR sky130_fd_sc_hd__decap_3
XFILLER_17_431 VGND VGND VPWR VPWR sky130_fd_sc_hd__decap_3
XFILLER_36_239 VGND VGND VPWR VPWR sky130_fd_sc_hd__decap_3
XFILLER_64_548 VGND VGND VPWR VPWR sky130_fd_sc_hd__decap_3
XFILLER_91_334 VGND VGND VPWR VPWR sky130_fd_sc_hd__fill_2
XFILLER_91_356 VGND VGND VPWR VPWR sky130_fd_sc_hd__fill_2
XTAP_TAPCELL_ROW_67_1051 VGND VPWR sky130_fd_sc_hd__tapvpwrvgnd_1
XPHY_EDGE_ROW_103_Left_220 VGND VGND VPWR VPWR sky130_fd_sc_hd__decap_3
XFILLER_44_283 VGND VGND VPWR VPWR sky130_fd_sc_hd__decap_3
XFILLER_72_592 VGND VGND VPWR VPWR sky130_fd_sc_hd__decap_3
XFILLER_83_94 VGND VGND VPWR VPWR sky130_fd_sc_hd__fill_1
XFILLER_20_607 VGND VGND VPWR VPWR sky130_fd_sc_hd__decap_3
XFILLER_32_445 VGND VGND VPWR VPWR sky130_fd_sc_hd__decap_3
XFILLER_32_489 VGND VGND VPWR VPWR sky130_fd_sc_hd__fill_2
X_3770_ hold935/X _3822_/A2 _4944_/B VGND VGND VPWR VPWR _7393_/D sky130_fd_sc_hd__a21o_2
XTAP_TAPCELL_ROW_30_613 VGND VPWR sky130_fd_sc_hd__tapvpwrvgnd_1
XFILLER_9_641 VGND VGND VPWR VPWR sky130_fd_sc_hd__decap_3
XFILLER_9_685 VGND VGND VPWR VPWR sky130_fd_sc_hd__decap_3
XFILLER_66_3 VGND VGND VPWR VPWR sky130_fd_sc_hd__decap_3
XFILLER_8_184 VGND VGND VPWR VPWR sky130_fd_sc_hd__decap_3
XTAP_TAPCELL_ROW_10_370 VGND VPWR sky130_fd_sc_hd__tapvpwrvgnd_1
X_5371_ _5371_/A0 _4771_/X _5383_/S VGND VGND VPWR VPWR _7147_/D sky130_fd_sc_hd__mux2_2
XFILLER_113_211 VGND VGND VPWR VPWR sky130_fd_sc_hd__decap_3
X_7110_ _7332_/CLK _7110_/D _6390_/Y VGND VGND VPWR VPWR _7110_/Q sky130_fd_sc_hd__dfrtp_2
Xoutput459 _5650_/Y VGND VGND VPWR VPWR alu_result_out[0] sky130_fd_sc_hd__clkdlybuf4s25_1
X_4322_ _7290_/Q _5108_/S _4352_/B1 _7162_/Q _4321_/X VGND VGND VPWR VPWR _4322_/X
+ sky130_fd_sc_hd__a221o_2
XTAP_TAPCELL_ROW_78_1191 VGND VPWR sky130_fd_sc_hd__tapvpwrvgnd_1
X_7041_ _7392_/CLK _7041_/D _6321_/Y VGND VGND VPWR VPWR _7041_/Q sky130_fd_sc_hd__dfrtp_2
X_4253_ _7389_/Q _4346_/B1 _5080_/S _7293_/Q _4252_/X VGND VGND VPWR VPWR _4253_/X
+ sky130_fd_sc_hd__a221o_2
XFILLER_113_266 VGND VGND VPWR VPWR sky130_fd_sc_hd__decap_3
XFILLER_87_629 VGND VGND VPWR VPWR sky130_fd_sc_hd__decap_3
XFILLER_99_489 VGND VGND VPWR VPWR sky130_fd_sc_hd__decap_3
XFILLER_86_139 VGND VGND VPWR VPWR sky130_fd_sc_hd__fill_1
X_4184_ _7296_/Q _4979_/S _4351_/A2 _7104_/Q _4183_/X VGND VGND VPWR VPWR _4185_/C
+ sky130_fd_sc_hd__a221o_2
XFILLER_95_662 VGND VGND VPWR VPWR sky130_fd_sc_hd__decap_3
XFILLER_95_673 VGND VGND VPWR VPWR sky130_fd_sc_hd__decap_3
XTAP_TAPCELL_ROW_38_713 VGND VPWR sky130_fd_sc_hd__tapvpwrvgnd_1
XTAP_TAPCELL_ROW_38_702 VGND VPWR sky130_fd_sc_hd__tapvpwrvgnd_1
XFILLER_67_386 VGND VGND VPWR VPWR sky130_fd_sc_hd__decap_3
XFILLER_82_312 VGND VGND VPWR VPWR sky130_fd_sc_hd__decap_3
XFILLER_63_570 VGND VGND VPWR VPWR sky130_fd_sc_hd__decap_3
XTAP_TAPCELL_ROW_18_470 VGND VPWR sky130_fd_sc_hd__tapvpwrvgnd_1
X_6825_ _6970_/CLK _6825_/D VGND VGND VPWR VPWR _6825_/Q sky130_fd_sc_hd__dfxtp_2
XFILLER_11_629 VGND VGND VPWR VPWR sky130_fd_sc_hd__decap_3
XFILLER_50_253 VGND VGND VPWR VPWR sky130_fd_sc_hd__decap_3
X_6756_ _6974_/CLK _6756_/D VGND VGND VPWR VPWR _6756_/Q sky130_fd_sc_hd__dfxtp_2
X_3968_ _7356_/Q _7324_/Q _3968_/S VGND VGND VPWR VPWR _7356_/D sky130_fd_sc_hd__mux2_2
XFILLER_10_128 VGND VGND VPWR VPWR sky130_fd_sc_hd__decap_3
XFILLER_50_286 VGND VGND VPWR VPWR sky130_fd_sc_hd__fill_1
XFILLER_50_297 VGND VGND VPWR VPWR sky130_fd_sc_hd__decap_3
XFILLER_109_517 VGND VGND VPWR VPWR sky130_fd_sc_hd__decap_3
X_6687_ _6965_/CLK _6687_/D VGND VGND VPWR VPWR _6687_/Q sky130_fd_sc_hd__dfxtp_2
X_3899_ _6693_/Q _3903_/B1 _3922_/B1 _6871_/Q _3746_/C VGND VGND VPWR VPWR _3899_/X
+ sky130_fd_sc_hd__a221o_2
X_5569_ hold951/X _4960_/A _4910_/B VGND VGND VPWR VPWR _7048_/D sky130_fd_sc_hd__a21bo_2
XFILLER_104_200 VGND VGND VPWR VPWR sky130_fd_sc_hd__decap_3
X_7308_ _7372_/CLK _7308_/D _6588_/Y VGND VGND VPWR VPWR _7308_/Q sky130_fd_sc_hd__dfrtp_2
XFILLER_78_607 VGND VGND VPWR VPWR sky130_fd_sc_hd__decap_3
X_7239_ _7403_/CLK _7239_/D _6519_/Y VGND VGND VPWR VPWR _7239_/Q sky130_fd_sc_hd__dfrtp_2
XFILLER_86_640 VGND VGND VPWR VPWR sky130_fd_sc_hd__decap_3
XFILLER_86_651 VGND VGND VPWR VPWR sky130_fd_sc_hd__decap_3
XFILLER_18_206 VGND VGND VPWR VPWR sky130_fd_sc_hd__decap_3
XFILLER_86_684 VGND VGND VPWR VPWR sky130_fd_sc_hd__decap_3
XFILLER_100_483 VGND VGND VPWR VPWR sky130_fd_sc_hd__decap_3
XFILLER_85_172 VGND VGND VPWR VPWR sky130_fd_sc_hd__decap_3
XFILLER_85_194 VGND VGND VPWR VPWR sky130_fd_sc_hd__decap_3
XFILLER_73_367 VGND VGND VPWR VPWR sky130_fd_sc_hd__decap_3
XFILLER_14_401 VGND VGND VPWR VPWR sky130_fd_sc_hd__decap_3
XFILLER_54_581 VGND VGND VPWR VPWR sky130_fd_sc_hd__decap_3
XFILLER_41_231 VGND VGND VPWR VPWR sky130_fd_sc_hd__decap_3
XFILLER_54_592 VGND VGND VPWR VPWR sky130_fd_sc_hd__decap_3
XFILLER_41_264 VGND VGND VPWR VPWR sky130_fd_sc_hd__decap_3
XFILLER_10_640 VGND VGND VPWR VPWR sky130_fd_sc_hd__decap_3
XFILLER_10_651 VGND VGND VPWR VPWR sky130_fd_sc_hd__decap_3
XFILLER_10_684 VGND VGND VPWR VPWR sky130_fd_sc_hd__decap_3
XFILLER_6_622 VGND VGND VPWR VPWR sky130_fd_sc_hd__decap_3
XFILLER_6_666 VGND VGND VPWR VPWR sky130_fd_sc_hd__decap_3
XFILLER_108_572 VGND VGND VPWR VPWR sky130_fd_sc_hd__decap_3
XFILLER_5_187 VGND VGND VPWR VPWR sky130_fd_sc_hd__decap_3
XTAP_TAPCELL_ROW_114_1623 VGND VPWR sky130_fd_sc_hd__tapvpwrvgnd_1
XFILLER_68_128 VGND VGND VPWR VPWR sky130_fd_sc_hd__decap_3
XFILLER_69_629 VGND VGND VPWR VPWR sky130_fd_sc_hd__decap_3
XFILLER_78_94 VGND VGND VPWR VPWR sky130_fd_sc_hd__decap_3
XFILLER_110_225 VGND VGND VPWR VPWR sky130_fd_sc_hd__decap_3
XFILLER_64_301 VGND VGND VPWR VPWR sky130_fd_sc_hd__decap_3
XFILLER_77_662 VGND VGND VPWR VPWR sky130_fd_sc_hd__decap_3
XFILLER_77_673 VGND VGND VPWR VPWR sky130_fd_sc_hd__decap_3
XFILLER_92_610 VGND VGND VPWR VPWR sky130_fd_sc_hd__decap_3
XFILLER_64_323 VGND VGND VPWR VPWR sky130_fd_sc_hd__decap_3
XFILLER_76_172 VGND VGND VPWR VPWR sky130_fd_sc_hd__decap_3
XFILLER_92_643 VGND VGND VPWR VPWR sky130_fd_sc_hd__fill_1
XFILLER_37_559 VGND VGND VPWR VPWR sky130_fd_sc_hd__fill_1
XFILLER_91_131 VGND VGND VPWR VPWR sky130_fd_sc_hd__decap_3
XFILLER_92_654 VGND VGND VPWR VPWR sky130_fd_sc_hd__decap_3
XFILLER_94_82 VGND VGND VPWR VPWR sky130_fd_sc_hd__fill_2
XFILLER_45_570 VGND VGND VPWR VPWR sky130_fd_sc_hd__decap_3
XFILLER_92_687 VGND VGND VPWR VPWR sky130_fd_sc_hd__decap_3
X_4940_ _4814_/A _4937_/Y _4939_/X VGND VGND VPWR VPWR _4940_/Y sky130_fd_sc_hd__o21ai_2
X_4871_ _4845_/A _4643_/Y _4841_/Y _4948_/A VGND VGND VPWR VPWR _4871_/Y sky130_fd_sc_hd__a31oi_2
XFILLER_32_253 VGND VGND VPWR VPWR sky130_fd_sc_hd__decap_3
XFILLER_32_275 VGND VGND VPWR VPWR sky130_fd_sc_hd__decap_3
XFILLER_60_573 VGND VGND VPWR VPWR sky130_fd_sc_hd__decap_3
X_6610_ _6610_/A VGND VGND VPWR VPWR _6610_/Y sky130_fd_sc_hd__inv_2
X_3822_ hold969/X _3822_/A2 _5010_/C VGND VGND VPWR VPWR _7389_/D sky130_fd_sc_hd__a21o_2
XTAP_TAPCELL_ROW_43_771 VGND VPWR sky130_fd_sc_hd__tapvpwrvgnd_1
XFILLER_20_437 VGND VGND VPWR VPWR sky130_fd_sc_hd__decap_3
XFILLER_60_595 VGND VGND VPWR VPWR sky130_fd_sc_hd__decap_3
X_6541_ _6542_/A VGND VGND VPWR VPWR _6541_/Y sky130_fd_sc_hd__inv_2
X_3753_ _3682_/A _3752_/X _4791_/A1 VGND VGND VPWR VPWR _3753_/X sky130_fd_sc_hd__a21o_2
X_6472_ _6624_/A VGND VGND VPWR VPWR _6472_/Y sky130_fd_sc_hd__inv_2
X_3684_ hold979/X _3822_/A2 _3683_/Y VGND VGND VPWR VPWR _7404_/D sky130_fd_sc_hd__a21bo_2
X_5423_ _5423_/A0 _5139_/X _5425_/S VGND VGND VPWR VPWR _7122_/D sky130_fd_sc_hd__mux2_2
X_5354_ _5354_/A0 _5139_/X _5354_/S VGND VGND VPWR VPWR _7154_/D sky130_fd_sc_hd__mux2_2
XFILLER_114_531 VGND VGND VPWR VPWR sky130_fd_sc_hd__fill_1
XFILLER_114_542 VGND VGND VPWR VPWR sky130_fd_sc_hd__decap_3
X_4305_ _7064_/Q _4305_/B VGND VGND VPWR VPWR _4364_/B sky130_fd_sc_hd__nor2_2
XFILLER_99_253 VGND VGND VPWR VPWR sky130_fd_sc_hd__decap_3
XFILLER_99_231 VGND VGND VPWR VPWR sky130_fd_sc_hd__decap_3
XFILLER_101_214 VGND VGND VPWR VPWR sky130_fd_sc_hd__decap_3
XFILLER_114_575 VGND VGND VPWR VPWR sky130_fd_sc_hd__decap_3
XFILLER_59_106 VGND VGND VPWR VPWR sky130_fd_sc_hd__decap_3
XFILLER_59_128 VGND VGND VPWR VPWR sky130_fd_sc_hd__fill_1
XFILLER_99_264 VGND VGND VPWR VPWR sky130_fd_sc_hd__decap_3
XFILLER_101_236 VGND VGND VPWR VPWR sky130_fd_sc_hd__decap_3
XFILLER_114_15 VGND VGND VPWR VPWR sky130_fd_sc_hd__decap_3
XFILLER_68_640 VGND VGND VPWR VPWR sky130_fd_sc_hd__decap_3
X_7024_ _7372_/CLK _7024_/D _6304_/Y VGND VGND VPWR VPWR _7024_/Q sky130_fd_sc_hd__dfrtp_2
X_4236_ _7163_/Q _4318_/B1 _4234_/X _4235_/X VGND VGND VPWR VPWR _4236_/X sky130_fd_sc_hd__a211o_2
XFILLER_28_515 VGND VGND VPWR VPWR sky130_fd_sc_hd__decap_3
XFILLER_68_651 VGND VGND VPWR VPWR sky130_fd_sc_hd__decap_3
XFILLER_68_684 VGND VGND VPWR VPWR sky130_fd_sc_hd__decap_3
XFILLER_74_109 VGND VGND VPWR VPWR sky130_fd_sc_hd__decap_3
X_4167_ _7393_/Q _4419_/B1 _4946_/S _7297_/Q _4166_/X VGND VGND VPWR VPWR _4167_/X
+ sky130_fd_sc_hd__a221o_2
XFILLER_114_59 VGND VGND VPWR VPWR sky130_fd_sc_hd__decap_3
XFILLER_28_548 VGND VGND VPWR VPWR sky130_fd_sc_hd__decap_3
XFILLER_55_334 VGND VGND VPWR VPWR sky130_fd_sc_hd__fill_2
XFILLER_83_632 VGND VGND VPWR VPWR sky130_fd_sc_hd__decap_3
XFILLER_55_356 VGND VGND VPWR VPWR sky130_fd_sc_hd__decap_3
XFILLER_83_665 VGND VGND VPWR VPWR sky130_fd_sc_hd__decap_3
XFILLER_83_676 VGND VGND VPWR VPWR sky130_fd_sc_hd__decap_3
X_4098_ _7333_/Q _3954_/S _4261_/A2 _7365_/Q _4347_/C1 VGND VGND VPWR VPWR _4098_/X
+ sky130_fd_sc_hd__a221o_2
XFILLER_15_209 VGND VGND VPWR VPWR sky130_fd_sc_hd__decap_3
XFILLER_36_581 VGND VGND VPWR VPWR sky130_fd_sc_hd__decap_3
XFILLER_55_389 VGND VGND VPWR VPWR sky130_fd_sc_hd__decap_3
XFILLER_70_315 VGND VGND VPWR VPWR sky130_fd_sc_hd__decap_3
XFILLER_82_164 VGND VGND VPWR VPWR sky130_fd_sc_hd__decap_3
XFILLER_36_592 VGND VGND VPWR VPWR sky130_fd_sc_hd__decap_3
XFILLER_90_18 VGND VGND VPWR VPWR sky130_fd_sc_hd__fill_2
XFILLER_51_573 VGND VGND VPWR VPWR sky130_fd_sc_hd__decap_3
X_6808_ _6965_/CLK _6808_/D VGND VGND VPWR VPWR _6808_/Q sky130_fd_sc_hd__dfxtp_2
XFILLER_11_437 VGND VGND VPWR VPWR sky130_fd_sc_hd__decap_3
X_6739_ clkload9/A _6739_/D VGND VGND VPWR VPWR _6739_/Q sky130_fd_sc_hd__dfxtp_2
XFILLER_109_325 VGND VGND VPWR VPWR sky130_fd_sc_hd__fill_2
XFILLER_3_603 VGND VGND VPWR VPWR sky130_fd_sc_hd__decap_3
XTAP_TAPCELL_ROW_21_498 VGND VPWR sky130_fd_sc_hd__tapvpwrvgnd_1
XFILLER_105_520 VGND VGND VPWR VPWR sky130_fd_sc_hd__decap_3
XFILLER_105_553 VGND VGND VPWR VPWR sky130_fd_sc_hd__decap_3
XFILLER_2_124 VGND VGND VPWR VPWR sky130_fd_sc_hd__decap_3
XFILLER_3_647 VGND VGND VPWR VPWR sky130_fd_sc_hd__decap_3
XFILLER_105_564 VGND VGND VPWR VPWR sky130_fd_sc_hd__decap_3
XFILLER_105_597 VGND VGND VPWR VPWR sky130_fd_sc_hd__decap_3
XFILLER_2_179 VGND VGND VPWR VPWR sky130_fd_sc_hd__fill_1
XFILLER_78_437 VGND VGND VPWR VPWR sky130_fd_sc_hd__decap_3
XFILLER_48_53 VGND VGND VPWR VPWR sky130_fd_sc_hd__fill_1
XFILLER_59_662 VGND VGND VPWR VPWR sky130_fd_sc_hd__decap_3
XFILLER_59_673 VGND VGND VPWR VPWR sky130_fd_sc_hd__decap_3
XFILLER_0_16 VGND VGND VPWR VPWR sky130_fd_sc_hd__fill_1
XFILLER_19_537 VGND VGND VPWR VPWR sky130_fd_sc_hd__decap_3
XFILLER_46_312 VGND VGND VPWR VPWR sky130_fd_sc_hd__fill_2
XFILLER_46_323 VGND VGND VPWR VPWR sky130_fd_sc_hd__decap_3
XFILLER_74_610 VGND VGND VPWR VPWR sky130_fd_sc_hd__decap_3
XFILLER_74_643 VGND VGND VPWR VPWR sky130_fd_sc_hd__fill_1
XFILLER_73_153 VGND VGND VPWR VPWR sky130_fd_sc_hd__decap_3
XFILLER_74_654 VGND VGND VPWR VPWR sky130_fd_sc_hd__decap_3
XFILLER_27_570 VGND VGND VPWR VPWR sky130_fd_sc_hd__decap_3
XFILLER_61_326 VGND VGND VPWR VPWR sky130_fd_sc_hd__fill_2
XFILLER_64_41 VGND VGND VPWR VPWR sky130_fd_sc_hd__decap_3
XFILLER_74_687 VGND VGND VPWR VPWR sky130_fd_sc_hd__decap_3
XFILLER_61_337 VGND VGND VPWR VPWR sky130_fd_sc_hd__fill_1
XFILLER_64_85 VGND VGND VPWR VPWR sky130_fd_sc_hd__decap_3
XTAP_TAPCELL_ROW_64_1021 VGND VPWR sky130_fd_sc_hd__tapvpwrvgnd_1
XTAP_TAPCELL_ROW_29_598 VGND VPWR sky130_fd_sc_hd__tapvpwrvgnd_1
XFILLER_14_242 VGND VGND VPWR VPWR sky130_fd_sc_hd__fill_2
XFILLER_14_253 VGND VGND VPWR VPWR sky130_fd_sc_hd__decap_3
XFILLER_14_264 VGND VGND VPWR VPWR sky130_fd_sc_hd__decap_3
XFILLER_42_551 VGND VGND VPWR VPWR sky130_fd_sc_hd__decap_3
XFILLER_9_14 VGND VGND VPWR VPWR sky130_fd_sc_hd__fill_2
XFILLER_42_584 VGND VGND VPWR VPWR sky130_fd_sc_hd__decap_3
XFILLER_42_595 VGND VGND VPWR VPWR sky130_fd_sc_hd__decap_3
XTAP_TAPCELL_ROW_40_730 VGND VPWR sky130_fd_sc_hd__tapvpwrvgnd_1
XFILLER_6_452 VGND VGND VPWR VPWR sky130_fd_sc_hd__decap_3
Xhold909 _6707_/Q VGND VGND VPWR VPWR hold909/X sky130_fd_sc_hd__dlygate4sd3_1
XFILLER_115_317 VGND VGND VPWR VPWR sky130_fd_sc_hd__fill_2
XFILLER_115_328 VGND VGND VPWR VPWR sky130_fd_sc_hd__fill_2
XTAP_TAPCELL_ROW_75_1150 VGND VPWR sky130_fd_sc_hd__tapvpwrvgnd_1
XFILLER_111_523 VGND VGND VPWR VPWR sky130_fd_sc_hd__decap_3
XFILLER_111_556 VGND VGND VPWR VPWR sky130_fd_sc_hd__decap_3
X_5070_ _5073_/A _5050_/X _5053_/Y VGND VGND VPWR VPWR _5075_/A sky130_fd_sc_hd__o21a_2
XFILLER_111_567 VGND VGND VPWR VPWR sky130_fd_sc_hd__decap_3
XFILLER_37_301 VGND VGND VPWR VPWR sky130_fd_sc_hd__decap_3
XFILLER_65_632 VGND VGND VPWR VPWR sky130_fd_sc_hd__decap_3
XFILLER_77_492 VGND VGND VPWR VPWR sky130_fd_sc_hd__decap_3
XTAP_TAPCELL_ROW_48_830 VGND VPWR sky130_fd_sc_hd__tapvpwrvgnd_1
XFILLER_37_334 VGND VGND VPWR VPWR sky130_fd_sc_hd__fill_2
XFILLER_64_131 VGND VGND VPWR VPWR sky130_fd_sc_hd__fill_1
XFILLER_65_665 VGND VGND VPWR VPWR sky130_fd_sc_hd__decap_3
XFILLER_65_676 VGND VGND VPWR VPWR sky130_fd_sc_hd__decap_3
XFILLER_52_315 VGND VGND VPWR VPWR sky130_fd_sc_hd__decap_3
XFILLER_64_164 VGND VGND VPWR VPWR sky130_fd_sc_hd__decap_3
XFILLER_80_613 VGND VGND VPWR VPWR sky130_fd_sc_hd__decap_3
XFILLER_18_581 VGND VGND VPWR VPWR sky130_fd_sc_hd__decap_3
XFILLER_18_592 VGND VGND VPWR VPWR sky130_fd_sc_hd__decap_3
XFILLER_64_197 VGND VGND VPWR VPWR sky130_fd_sc_hd__fill_2
XFILLER_80_657 VGND VGND VPWR VPWR sky130_fd_sc_hd__decap_3
X_4923_ _4920_/A _4922_/X _4969_/B VGND VGND VPWR VPWR _4923_/Y sky130_fd_sc_hd__o21ai_2
XFILLER_33_573 VGND VGND VPWR VPWR sky130_fd_sc_hd__decap_3
X_4854_ _4764_/B _4096_/A _4633_/A _5101_/A VGND VGND VPWR VPWR _4854_/X sky130_fd_sc_hd__o22a_2
XFILLER_20_256 VGND VGND VPWR VPWR sky130_fd_sc_hd__decap_3
X_4785_ _4785_/A _4811_/B VGND VGND VPWR VPWR _4795_/B sky130_fd_sc_hd__nand2_2
X_3805_ _6948_/Q _3903_/B1 _3883_/B1 _6960_/Q VGND VGND VPWR VPWR _3805_/X sky130_fd_sc_hd__a22o_2
X_6524_ _6620_/A VGND VGND VPWR VPWR _6524_/Y sky130_fd_sc_hd__inv_2
XFILLER_109_26 VGND VGND VPWR VPWR sky130_fd_sc_hd__decap_3
XFILLER_106_339 VGND VGND VPWR VPWR sky130_fd_sc_hd__decap_3
X_6455_ _6617_/A VGND VGND VPWR VPWR _6455_/Y sky130_fd_sc_hd__inv_2
X_6386_ _6581_/A VGND VGND VPWR VPWR _6386_/Y sky130_fd_sc_hd__inv_2
X_3598_ _3598_/A _3611_/B VGND VGND VPWR VPWR _4614_/B sky130_fd_sc_hd__nor2_2
XFILLER_0_617 VGND VGND VPWR VPWR sky130_fd_sc_hd__decap_3
XFILLER_102_501 VGND VGND VPWR VPWR sky130_fd_sc_hd__decap_3
XFILLER_102_545 VGND VGND VPWR VPWR sky130_fd_sc_hd__decap_3
X_5268_ hold998/X _5027_/X _5286_/S VGND VGND VPWR VPWR _7196_/D sky130_fd_sc_hd__mux2_2
XFILLER_102_578 VGND VGND VPWR VPWR sky130_fd_sc_hd__decap_3
XFILLER_102_589 VGND VGND VPWR VPWR sky130_fd_sc_hd__decap_3
X_7007_ _7374_/CLK _7007_/D _6287_/Y VGND VGND VPWR VPWR _7007_/Q sky130_fd_sc_hd__dfrtp_2
X_4219_ _7292_/Q _5080_/S _4267_/B1 _7164_/Q _4218_/X VGND VGND VPWR VPWR _4219_/X
+ sky130_fd_sc_hd__a221o_2
XTAP_TAPCELL_ROW_89_1319 VGND VPWR sky130_fd_sc_hd__tapvpwrvgnd_1
XFILLER_28_312 VGND VGND VPWR VPWR sky130_fd_sc_hd__decap_3
XFILLER_56_610 VGND VGND VPWR VPWR sky130_fd_sc_hd__decap_3
XFILLER_56_643 VGND VGND VPWR VPWR sky130_fd_sc_hd__fill_1
XFILLER_56_654 VGND VGND VPWR VPWR sky130_fd_sc_hd__decap_3
XFILLER_16_529 VGND VGND VPWR VPWR sky130_fd_sc_hd__decap_3
XFILLER_43_326 VGND VGND VPWR VPWR sky130_fd_sc_hd__decap_3
XFILLER_56_687 VGND VGND VPWR VPWR sky130_fd_sc_hd__decap_3
XFILLER_71_635 VGND VGND VPWR VPWR sky130_fd_sc_hd__decap_3
XFILLER_34_22 VGND VGND VPWR VPWR sky130_fd_sc_hd__decap_3
XFILLER_70_112 VGND VGND VPWR VPWR sky130_fd_sc_hd__decap_3
XFILLER_71_668 VGND VGND VPWR VPWR sky130_fd_sc_hd__decap_3
XFILLER_24_551 VGND VGND VPWR VPWR sky130_fd_sc_hd__decap_3
XFILLER_71_679 VGND VGND VPWR VPWR sky130_fd_sc_hd__decap_3
XTAP_TAPCELL_ROW_26_568 VGND VPWR sky130_fd_sc_hd__tapvpwrvgnd_1
XFILLER_11_201 VGND VGND VPWR VPWR sky130_fd_sc_hd__decap_3
XFILLER_24_584 VGND VGND VPWR VPWR sky130_fd_sc_hd__decap_3
XFILLER_24_595 VGND VGND VPWR VPWR sky130_fd_sc_hd__decap_3
XTAP_TAPCELL_ROW_54_899 VGND VPWR sky130_fd_sc_hd__tapvpwrvgnd_1
XFILLER_7_205 VGND VGND VPWR VPWR sky130_fd_sc_hd__decap_3
XFILLER_3_499 VGND VGND VPWR VPWR sky130_fd_sc_hd__decap_3
XFILLER_59_63 VGND VGND VPWR VPWR sky130_fd_sc_hd__decap_3
XFILLER_78_212 VGND VGND VPWR VPWR sky130_fd_sc_hd__decap_3
XFILLER_78_256 VGND VGND VPWR VPWR sky130_fd_sc_hd__decap_3
XFILLER_47_632 VGND VGND VPWR VPWR sky130_fd_sc_hd__decap_3
XFILLER_59_481 VGND VGND VPWR VPWR sky130_fd_sc_hd__decap_3
XTAP_TAPCELL_ROW_70_1091 VGND VPWR sky130_fd_sc_hd__tapvpwrvgnd_1
XFILLER_47_665 VGND VGND VPWR VPWR sky130_fd_sc_hd__decap_3
XFILLER_93_259 VGND VGND VPWR VPWR sky130_fd_sc_hd__decap_3
XTAP_TAPCELL_ROW_109_1555 VGND VPWR sky130_fd_sc_hd__tapvpwrvgnd_1
XFILLER_19_389 VGND VGND VPWR VPWR sky130_fd_sc_hd__decap_3
XFILLER_47_676 VGND VGND VPWR VPWR sky130_fd_sc_hd__decap_3
XFILLER_62_613 VGND VGND VPWR VPWR sky130_fd_sc_hd__decap_3
XFILLER_34_348 VGND VGND VPWR VPWR sky130_fd_sc_hd__decap_3
XFILLER_62_657 VGND VGND VPWR VPWR sky130_fd_sc_hd__decap_3
XFILLER_61_178 VGND VGND VPWR VPWR sky130_fd_sc_hd__decap_3
XFILLER_15_573 VGND VGND VPWR VPWR sky130_fd_sc_hd__decap_3
XFILLER_70_690 VGND VGND VPWR VPWR sky130_fd_sc_hd__fill_1
XFILLER_30_576 VGND VGND VPWR VPWR sky130_fd_sc_hd__decap_3
XFILLER_30_598 VGND VGND VPWR VPWR sky130_fd_sc_hd__decap_3
X_3521_ _3525_/A _3525_/B VGND VGND VPWR VPWR _3521_/Y sky130_fd_sc_hd__nand2_2
XFILLER_116_615 VGND VGND VPWR VPWR sky130_fd_sc_hd__fill_1
XFILLER_116_637 VGND VGND VPWR VPWR sky130_fd_sc_hd__decap_3
Xhold706 _6938_/Q VGND VGND VPWR VPWR _6938_/D sky130_fd_sc_hd__dlygate4sd3_1
Xhold717 _6787_/Q VGND VGND VPWR VPWR _6787_/D sky130_fd_sc_hd__dlygate4sd3_1
Xhold728 _6739_/Q VGND VGND VPWR VPWR _6739_/D sky130_fd_sc_hd__dlygate4sd3_1
XFILLER_115_125 VGND VGND VPWR VPWR sky130_fd_sc_hd__decap_3
XFILLER_115_158 VGND VGND VPWR VPWR sky130_fd_sc_hd__fill_2
XFILLER_116_659 VGND VGND VPWR VPWR sky130_fd_sc_hd__decap_3
Xhold739 _6735_/Q VGND VGND VPWR VPWR _6735_/D sky130_fd_sc_hd__dlygate4sd3_1
XFILLER_115_169 VGND VGND VPWR VPWR sky130_fd_sc_hd__decap_3
X_3383_ _5118_/D _3383_/B VGND VGND VPWR VPWR _3383_/Y sky130_fd_sc_hd__nor2_2
XFILLER_69_223 VGND VGND VPWR VPWR sky130_fd_sc_hd__fill_1
XFILLER_69_234 VGND VGND VPWR VPWR sky130_fd_sc_hd__decap_3
XFILLER_97_532 VGND VGND VPWR VPWR sky130_fd_sc_hd__decap_3
X_5122_ hold995/X _5121_/X _5159_/S VGND VGND VPWR VPWR _7254_/D sky130_fd_sc_hd__mux2_2
XFILLER_69_245 VGND VGND VPWR VPWR sky130_fd_sc_hd__decap_3
XFILLER_69_278 VGND VGND VPWR VPWR sky130_fd_sc_hd__fill_2
XFILLER_97_576 VGND VGND VPWR VPWR sky130_fd_sc_hd__decap_3
XFILLER_38_610 VGND VGND VPWR VPWR sky130_fd_sc_hd__decap_3
X_5053_ _5073_/A _5050_/X _3522_/Y VGND VGND VPWR VPWR _5053_/Y sky130_fd_sc_hd__a21oi_2
XFILLER_38_643 VGND VGND VPWR VPWR sky130_fd_sc_hd__fill_1
XFILLER_38_654 VGND VGND VPWR VPWR sky130_fd_sc_hd__decap_3
XFILLER_84_259 VGND VGND VPWR VPWR sky130_fd_sc_hd__decap_3
XFILLER_25_315 VGND VGND VPWR VPWR sky130_fd_sc_hd__decap_3
XFILLER_37_175 VGND VGND VPWR VPWR sky130_fd_sc_hd__decap_3
XFILLER_38_687 VGND VGND VPWR VPWR sky130_fd_sc_hd__decap_3
XFILLER_65_473 VGND VGND VPWR VPWR sky130_fd_sc_hd__decap_3
XFILLER_80_410 VGND VGND VPWR VPWR sky130_fd_sc_hd__fill_1
XFILLER_111_27 VGND VGND VPWR VPWR sky130_fd_sc_hd__decap_3
XFILLER_25_337 VGND VGND VPWR VPWR sky130_fd_sc_hd__decap_3
XFILLER_53_635 VGND VGND VPWR VPWR sky130_fd_sc_hd__decap_3
XFILLER_80_432 VGND VGND VPWR VPWR sky130_fd_sc_hd__decap_3
XFILLER_52_156 VGND VGND VPWR VPWR sky130_fd_sc_hd__fill_1
XFILLER_53_668 VGND VGND VPWR VPWR sky130_fd_sc_hd__decap_3
XFILLER_53_679 VGND VGND VPWR VPWR sky130_fd_sc_hd__decap_3
XFILLER_40_318 VGND VGND VPWR VPWR sky130_fd_sc_hd__fill_2
XFILLER_52_178 VGND VGND VPWR VPWR sky130_fd_sc_hd__fill_2
X_4906_ _4814_/A _4886_/C _4904_/X _4905_/X VGND VGND VPWR VPWR _4906_/X sky130_fd_sc_hd__o31a_2
XTAP_TAPCELL_ROW_23_527 VGND VPWR sky130_fd_sc_hd__tapvpwrvgnd_1
XFILLER_21_532 VGND VGND VPWR VPWR sky130_fd_sc_hd__decap_3
X_4837_ _4837_/A0 _4836_/X _4837_/S VGND VGND VPWR VPWR _7271_/D sky130_fd_sc_hd__mux2_2
XTAP_TAPCELL_ROW_51_869 VGND VPWR sky130_fd_sc_hd__tapvpwrvgnd_1
XTAP_TAPCELL_ROW_51_858 VGND VPWR sky130_fd_sc_hd__tapvpwrvgnd_1
XFILLER_21_576 VGND VGND VPWR VPWR sky130_fd_sc_hd__decap_3
X_4768_ _4762_/Y _4763_/X _4767_/X VGND VGND VPWR VPWR _4768_/Y sky130_fd_sc_hd__o21ai_2
XFILLER_106_114 VGND VGND VPWR VPWR sky130_fd_sc_hd__decap_3
XFILLER_107_615 VGND VGND VPWR VPWR sky130_fd_sc_hd__fill_1
XFILLER_107_626 VGND VGND VPWR VPWR sky130_fd_sc_hd__decap_3
X_6507_ _6571_/A VGND VGND VPWR VPWR _6507_/Y sky130_fd_sc_hd__inv_2
X_4699_ _6986_/Q _6987_/Q _5098_/A VGND VGND VPWR VPWR _5066_/A sky130_fd_sc_hd__and3_2
XFILLER_107_659 VGND VGND VPWR VPWR sky130_fd_sc_hd__decap_3
X_6438_ _6632_/A VGND VGND VPWR VPWR _6438_/Y sky130_fd_sc_hd__inv_2
XTAP_TAPCELL_ROW_95_1389 VGND VPWR sky130_fd_sc_hd__tapvpwrvgnd_1
XFILLER_0_414 VGND VGND VPWR VPWR sky130_fd_sc_hd__decap_3
XFILLER_29_11 VGND VGND VPWR VPWR sky130_fd_sc_hd__fill_1
X_6369_ _6567_/A VGND VGND VPWR VPWR _6369_/Y sky130_fd_sc_hd__inv_2
XFILLER_0_447 VGND VGND VPWR VPWR sky130_fd_sc_hd__fill_1
XFILLER_48_418 VGND VGND VPWR VPWR sky130_fd_sc_hd__fill_2
XFILLER_88_554 VGND VGND VPWR VPWR sky130_fd_sc_hd__decap_3
XFILLER_102_386 VGND VGND VPWR VPWR sky130_fd_sc_hd__decap_3
XFILLER_75_204 VGND VGND VPWR VPWR sky130_fd_sc_hd__fill_2
XFILLER_75_237 VGND VGND VPWR VPWR sky130_fd_sc_hd__decap_3
XFILLER_88_587 VGND VGND VPWR VPWR sky130_fd_sc_hd__fill_1
XFILLER_88_598 VGND VGND VPWR VPWR sky130_fd_sc_hd__decap_3
XFILLER_29_632 VGND VGND VPWR VPWR sky130_fd_sc_hd__decap_3
XFILLER_29_665 VGND VGND VPWR VPWR sky130_fd_sc_hd__decap_3
XTAP_TAPCELL_ROW_59_958 VGND VPWR sky130_fd_sc_hd__tapvpwrvgnd_1
XFILLER_28_153 VGND VGND VPWR VPWR sky130_fd_sc_hd__decap_3
XFILLER_29_676 VGND VGND VPWR VPWR sky130_fd_sc_hd__decap_3
XFILLER_44_613 VGND VGND VPWR VPWR sky130_fd_sc_hd__decap_3
XFILLER_56_462 VGND VGND VPWR VPWR sky130_fd_sc_hd__decap_3
XTAP_TAPCELL_ROW_3_285 VGND VPWR sky130_fd_sc_hd__tapvpwrvgnd_1
XFILLER_16_326 VGND VGND VPWR VPWR sky130_fd_sc_hd__fill_2
XFILLER_28_186 VGND VGND VPWR VPWR sky130_fd_sc_hd__decap_3
XFILLER_28_197 VGND VGND VPWR VPWR sky130_fd_sc_hd__decap_3
XFILLER_44_657 VGND VGND VPWR VPWR sky130_fd_sc_hd__decap_3
XFILLER_83_281 VGND VGND VPWR VPWR sky130_fd_sc_hd__decap_3
XFILLER_31_318 VGND VGND VPWR VPWR sky130_fd_sc_hd__decap_3
XFILLER_52_690 VGND VGND VPWR VPWR sky130_fd_sc_hd__fill_1
XFILLER_12_554 VGND VGND VPWR VPWR sky130_fd_sc_hd__decap_3
XTAP_TAPCELL_ROW_104_1496 VGND VPWR sky130_fd_sc_hd__tapvpwrvgnd_1
XFILLER_12_587 VGND VGND VPWR VPWR sky130_fd_sc_hd__fill_1
XFILLER_12_598 VGND VGND VPWR VPWR sky130_fd_sc_hd__decap_3
XFILLER_8_525 VGND VGND VPWR VPWR sky130_fd_sc_hd__decap_3
XFILLER_8_536 VGND VGND VPWR VPWR sky130_fd_sc_hd__decap_3
XFILLER_8_569 VGND VGND VPWR VPWR sky130_fd_sc_hd__decap_3
XANTENNA_8 _5177_/B VGND VGND VPWR VPWR sky130_fd_sc_hd__diode_2
XFILLER_113_629 VGND VGND VPWR VPWR sky130_fd_sc_hd__decap_3
XFILLER_98_307 VGND VGND VPWR VPWR sky130_fd_sc_hd__fill_1
XFILLER_106_681 VGND VGND VPWR VPWR sky130_fd_sc_hd__decap_3
XFILLER_79_521 VGND VGND VPWR VPWR sky130_fd_sc_hd__fill_1
XTAP_TAPCELL_ROW_72_1120 VGND VPWR sky130_fd_sc_hd__tapvpwrvgnd_1
XFILLER_79_554 VGND VGND VPWR VPWR sky130_fd_sc_hd__decap_3
XFILLER_79_576 VGND VGND VPWR VPWR sky130_fd_sc_hd__decap_3
XFILLER_39_429 VGND VGND VPWR VPWR sky130_fd_sc_hd__decap_3
XFILLER_66_259 VGND VGND VPWR VPWR sky130_fd_sc_hd__decap_3
XFILLER_94_557 VGND VGND VPWR VPWR sky130_fd_sc_hd__decap_3
XFILLER_19_186 VGND VGND VPWR VPWR sky130_fd_sc_hd__decap_3
XFILLER_35_635 VGND VGND VPWR VPWR sky130_fd_sc_hd__decap_3
XFILLER_62_421 VGND VGND VPWR VPWR sky130_fd_sc_hd__fill_2
XFILLER_35_668 VGND VGND VPWR VPWR sky130_fd_sc_hd__decap_3
XFILLER_35_679 VGND VGND VPWR VPWR sky130_fd_sc_hd__decap_3
XFILLER_50_616 VGND VGND VPWR VPWR sky130_fd_sc_hd__decap_3
XFILLER_62_454 VGND VGND VPWR VPWR sky130_fd_sc_hd__fill_2
XFILLER_15_370 VGND VGND VPWR VPWR sky130_fd_sc_hd__fill_1
XFILLER_22_329 VGND VGND VPWR VPWR sky130_fd_sc_hd__fill_2
XFILLER_96_3 VGND VGND VPWR VPWR sky130_fd_sc_hd__decap_3
XFILLER_30_351 VGND VGND VPWR VPWR sky130_fd_sc_hd__fill_2
X_5671_ _5671_/A _5671_/B VGND VGND VPWR VPWR _6983_/D sky130_fd_sc_hd__and2_2
XFILLER_30_384 VGND VGND VPWR VPWR sky130_fd_sc_hd__fill_2
X_4622_ _5072_/B _4621_/X _5071_/B VGND VGND VPWR VPWR _4622_/X sky130_fd_sc_hd__a21bo_2
X_7341_ _7406_/CLK _7341_/D _6621_/Y VGND VGND VPWR VPWR _7341_/Q sky130_fd_sc_hd__dfrtp_2
XFILLER_116_445 VGND VGND VPWR VPWR sky130_fd_sc_hd__decap_3
XFILLER_7_591 VGND VGND VPWR VPWR sky130_fd_sc_hd__decap_3
X_7272_ _7368_/CLK _7272_/D _6552_/Y VGND VGND VPWR VPWR _7272_/Q sky130_fd_sc_hd__dfrtp_2
X_4484_ _4484_/A0 _4550_/A _4488_/S VGND VGND VPWR VPWR _7337_/D sky130_fd_sc_hd__mux2_2
X_3504_ _3501_/X _3502_/X _3630_/A VGND VGND VPWR VPWR _3505_/B sky130_fd_sc_hd__a21oi_2
XFILLER_104_607 VGND VGND VPWR VPWR sky130_fd_sc_hd__decap_3
XFILLER_116_489 VGND VGND VPWR VPWR sky130_fd_sc_hd__fill_2
XFILLER_103_128 VGND VGND VPWR VPWR sky130_fd_sc_hd__fill_1
XFILLER_106_38 VGND VGND VPWR VPWR sky130_fd_sc_hd__decap_3
XFILLER_112_640 VGND VGND VPWR VPWR sky130_fd_sc_hd__decap_3
XFILLER_112_651 VGND VGND VPWR VPWR sky130_fd_sc_hd__decap_3
XFILLER_97_340 VGND VGND VPWR VPWR sky130_fd_sc_hd__decap_3
X_3366_ _3376_/A _3376_/B _3399_/B _5118_/A VGND VGND VPWR VPWR _3366_/X sky130_fd_sc_hd__o211a_2
XFILLER_112_684 VGND VGND VPWR VPWR sky130_fd_sc_hd__decap_3
XFILLER_85_524 VGND VGND VPWR VPWR sky130_fd_sc_hd__decap_3
Xhold1203 _7223_/Q VGND VGND VPWR VPWR _5211_/A sky130_fd_sc_hd__dlygate4sd3_1
Xhold1214 _7173_/Q VGND VGND VPWR VPWR _5315_/A0 sky130_fd_sc_hd__dlygate4sd3_1
Xhold1225 _7165_/Q VGND VGND VPWR VPWR _5331_/A0 sky130_fd_sc_hd__dlygate4sd3_1
X_5105_ _4467_/B _3874_/X _5104_/Y _5666_/A VGND VGND VPWR VPWR _5105_/X sky130_fd_sc_hd__a31o_2
XFILLER_85_557 VGND VGND VPWR VPWR sky130_fd_sc_hd__decap_3
X_5036_ _5036_/A _4674_/X VGND VGND VPWR VPWR _5038_/A sky130_fd_sc_hd__or2b_2
XFILLER_26_613 VGND VGND VPWR VPWR sky130_fd_sc_hd__decap_3
XFILLER_38_451 VGND VGND VPWR VPWR sky130_fd_sc_hd__decap_3
XFILLER_72_218 VGND VGND VPWR VPWR sky130_fd_sc_hd__fill_2
XFILLER_85_579 VGND VGND VPWR VPWR sky130_fd_sc_hd__decap_3
XTAP_TAPCELL_ROW_56_928 VGND VPWR sky130_fd_sc_hd__tapvpwrvgnd_1
XFILLER_26_657 VGND VGND VPWR VPWR sky130_fd_sc_hd__decap_3
XFILLER_65_281 VGND VGND VPWR VPWR sky130_fd_sc_hd__decap_3
XTAP_TAPCELL_ROW_0_244 VGND VPWR sky130_fd_sc_hd__tapvpwrvgnd_1
XFILLER_25_156 VGND VGND VPWR VPWR sky130_fd_sc_hd__decap_3
XFILLER_53_476 VGND VGND VPWR VPWR sky130_fd_sc_hd__decap_3
XFILLER_80_251 VGND VGND VPWR VPWR sky130_fd_sc_hd__fill_1
X_6987_ _7398_/CLK _6987_/D _6267_/Y VGND VGND VPWR VPWR _6987_/Q sky130_fd_sc_hd__dfrtp_2
XTAP_TAPCELL_ROW_0_255 VGND VPWR sky130_fd_sc_hd__tapvpwrvgnd_1
XFILLER_15_35 VGND VGND VPWR VPWR sky130_fd_sc_hd__decap_3
XFILLER_41_638 VGND VGND VPWR VPWR sky130_fd_sc_hd__decap_3
XTAP_TAPCELL_ROW_36_685 VGND VPWR sky130_fd_sc_hd__tapvpwrvgnd_1
XFILLER_34_690 VGND VGND VPWR VPWR sky130_fd_sc_hd__fill_1
XFILLER_80_295 VGND VGND VPWR VPWR sky130_fd_sc_hd__fill_2
XFILLER_21_351 VGND VGND VPWR VPWR sky130_fd_sc_hd__decap_3
XTAP_TAPCELL_ROW_97_1418 VGND VPWR sky130_fd_sc_hd__tapvpwrvgnd_1
XFILLER_5_517 VGND VGND VPWR VPWR sky130_fd_sc_hd__decap_3
XFILLER_107_467 VGND VGND VPWR VPWR sky130_fd_sc_hd__decap_3
XFILLER_0_200 VGND VGND VPWR VPWR sky130_fd_sc_hd__decap_3
XTAP_TAPCELL_ROW_8_344 VGND VPWR sky130_fd_sc_hd__tapvpwrvgnd_1
XFILLER_0_222 VGND VGND VPWR VPWR sky130_fd_sc_hd__fill_2
XFILLER_0_244 VGND VGND VPWR VPWR sky130_fd_sc_hd__decap_3
XFILLER_103_662 VGND VGND VPWR VPWR sky130_fd_sc_hd__decap_3
XFILLER_88_351 VGND VGND VPWR VPWR sky130_fd_sc_hd__decap_3
XFILLER_103_673 VGND VGND VPWR VPWR sky130_fd_sc_hd__decap_3
XFILLER_102_194 VGND VGND VPWR VPWR sky130_fd_sc_hd__fill_2
XFILLER_48_259 VGND VGND VPWR VPWR sky130_fd_sc_hd__decap_3
XFILLER_76_557 VGND VGND VPWR VPWR sky130_fd_sc_hd__decap_3
XFILLER_63_207 VGND VGND VPWR VPWR sky130_fd_sc_hd__decap_3
XFILLER_91_505 VGND VGND VPWR VPWR sky130_fd_sc_hd__decap_3
XFILLER_17_635 VGND VGND VPWR VPWR sky130_fd_sc_hd__decap_3
XFILLER_29_484 VGND VGND VPWR VPWR sky130_fd_sc_hd__fill_1
XFILLER_91_549 VGND VGND VPWR VPWR sky130_fd_sc_hd__decap_3
XTAP_TAPCELL_ROW_106_1525 VGND VPWR sky130_fd_sc_hd__tapvpwrvgnd_1
XFILLER_17_668 VGND VGND VPWR VPWR sky130_fd_sc_hd__decap_3
XFILLER_17_679 VGND VGND VPWR VPWR sky130_fd_sc_hd__decap_3
XFILLER_44_454 VGND VGND VPWR VPWR sky130_fd_sc_hd__decap_3
XFILLER_71_240 VGND VGND VPWR VPWR sky130_fd_sc_hd__decap_3
XPHY_EDGE_ROW_113_Right_113 VGND VGND VPWR VPWR sky130_fd_sc_hd__decap_3
XFILLER_31_104 VGND VGND VPWR VPWR sky130_fd_sc_hd__decap_3
XFILLER_32_616 VGND VGND VPWR VPWR sky130_fd_sc_hd__decap_3
XFILLER_71_284 VGND VGND VPWR VPWR sky130_fd_sc_hd__decap_3
XFILLER_72_85 VGND VGND VPWR VPWR sky130_fd_sc_hd__fill_2
XFILLER_40_660 VGND VGND VPWR VPWR sky130_fd_sc_hd__decap_3
XFILLER_12_384 VGND VGND VPWR VPWR sky130_fd_sc_hd__decap_3
XFILLER_113_426 VGND VGND VPWR VPWR sky130_fd_sc_hd__decap_3
XFILLER_4_572 VGND VGND VPWR VPWR sky130_fd_sc_hd__decap_3
XFILLER_99_638 VGND VGND VPWR VPWR sky130_fd_sc_hd__decap_3
XFILLER_98_115 VGND VGND VPWR VPWR sky130_fd_sc_hd__decap_3
XFILLER_79_340 VGND VGND VPWR VPWR sky130_fd_sc_hd__decap_3
XFILLER_79_384 VGND VGND VPWR VPWR sky130_fd_sc_hd__decap_3
XFILLER_39_248 VGND VGND VPWR VPWR sky130_fd_sc_hd__decap_3
XFILLER_67_579 VGND VGND VPWR VPWR sky130_fd_sc_hd__decap_3
XFILLER_82_516 VGND VGND VPWR VPWR sky130_fd_sc_hd__fill_1
XFILLER_94_365 VGND VGND VPWR VPWR sky130_fd_sc_hd__fill_1
XFILLER_35_432 VGND VGND VPWR VPWR sky130_fd_sc_hd__decap_3
XFILLER_47_281 VGND VGND VPWR VPWR sky130_fd_sc_hd__decap_3
X_6910_ _6968_/CLK _6910_/D VGND VGND VPWR VPWR _6910_/Q sky130_fd_sc_hd__dfxtp_2
XFILLER_90_560 VGND VGND VPWR VPWR sky130_fd_sc_hd__decap_3
X_6841_ clkload6/A _6841_/D VGND VGND VPWR VPWR _6841_/Q sky130_fd_sc_hd__dfxtp_2
XFILLER_23_638 VGND VGND VPWR VPWR sky130_fd_sc_hd__decap_3
XFILLER_50_424 VGND VGND VPWR VPWR sky130_fd_sc_hd__decap_3
XFILLER_62_284 VGND VGND VPWR VPWR sky130_fd_sc_hd__decap_3
XTAP_TAPCELL_ROW_81_1219 VGND VPWR sky130_fd_sc_hd__tapvpwrvgnd_1
XFILLER_16_690 VGND VGND VPWR VPWR sky130_fd_sc_hd__fill_1
X_6772_ _6968_/CLK _6772_/D VGND VGND VPWR VPWR _6772_/Q sky130_fd_sc_hd__dfxtp_2
XTAP_TAPCELL_ROW_33_644 VGND VPWR sky130_fd_sc_hd__tapvpwrvgnd_1
XFILLER_22_159 VGND VGND VPWR VPWR sky130_fd_sc_hd__decap_3
XFILLER_31_671 VGND VGND VPWR VPWR sky130_fd_sc_hd__fill_1
X_5723_ _7367_/Q hold946/X _5735_/S VGND VGND VPWR VPWR _6711_/D sky130_fd_sc_hd__mux2_2
XTAP_TAPCELL_ROW_61_986 VGND VPWR sky130_fd_sc_hd__tapvpwrvgnd_1
XFILLER_31_682 VGND VGND VPWR VPWR sky130_fd_sc_hd__decap_3
X_5654_ _5665_/A VGND VGND VPWR VPWR _5654_/Y sky130_fd_sc_hd__inv_2
XFILLER_108_209 VGND VGND VPWR VPWR sky130_fd_sc_hd__decap_3
XFILLER_7_91 VGND VGND VPWR VPWR sky130_fd_sc_hd__decap_3
X_7324_ _7328_/CLK _7324_/D _6604_/Y VGND VGND VPWR VPWR _7324_/Q sky130_fd_sc_hd__dfrtp_2
X_5585_ hold937/X _5587_/B _5106_/X VGND VGND VPWR VPWR _7036_/D sky130_fd_sc_hd__a21o_2
X_4536_ hold931/X _3398_/Y _3488_/X VGND VGND VPWR VPWR _7311_/D sky130_fd_sc_hd__a21o_2
XFILLER_89_137 VGND VGND VPWR VPWR sky130_fd_sc_hd__fill_1
X_7255_ _7353_/CLK _7255_/D _6535_/Y VGND VGND VPWR VPWR _7255_/Q sky130_fd_sc_hd__dfrtp_2
X_4467_ _4467_/A _4467_/B VGND VGND VPWR VPWR _5117_/A sky130_fd_sc_hd__nor2_2
XTAP_TAPCELL_ROW_92_1359 VGND VPWR sky130_fd_sc_hd__tapvpwrvgnd_1
X_7186_ _7355_/CLK _7186_/D _6466_/Y VGND VGND VPWR VPWR _7186_/Q sky130_fd_sc_hd__dfrtp_2
X_4398_ _7338_/Q _3954_/S _4491_/S _7306_/Q VGND VGND VPWR VPWR _4398_/X sky130_fd_sc_hd__a22o_2
X_3418_ _7283_/Q _5159_/S _3417_/X _7091_/Q VGND VGND VPWR VPWR _3418_/X sky130_fd_sc_hd__a22o_2
XFILLER_98_660 VGND VGND VPWR VPWR sky130_fd_sc_hd__decap_3
XFILLER_100_610 VGND VGND VPWR VPWR sky130_fd_sc_hd__decap_3
Xhold1000 _7191_/Q VGND VGND VPWR VPWR _5278_/A0 sky130_fd_sc_hd__dlygate4sd3_1
X_3349_ _3561_/A _5294_/A VGND VGND VPWR VPWR _3350_/B sky130_fd_sc_hd__nand2_2
XTAP_TAPCELL_ROW_5_314 VGND VPWR sky130_fd_sc_hd__tapvpwrvgnd_1
XFILLER_100_643 VGND VGND VPWR VPWR sky130_fd_sc_hd__fill_1
XFILLER_100_654 VGND VGND VPWR VPWR sky130_fd_sc_hd__decap_3
XFILLER_112_492 VGND VGND VPWR VPWR sky130_fd_sc_hd__decap_3
XFILLER_58_568 VGND VGND VPWR VPWR sky130_fd_sc_hd__decap_3
XFILLER_85_321 VGND VGND VPWR VPWR sky130_fd_sc_hd__decap_3
XFILLER_85_332 VGND VGND VPWR VPWR sky130_fd_sc_hd__decap_3
XFILLER_97_181 VGND VGND VPWR VPWR sky130_fd_sc_hd__decap_3
Xhold1011 _7253_/Q VGND VGND VPWR VPWR _5126_/A0 sky130_fd_sc_hd__dlygate4sd3_1
Xhold1022 _7263_/Q VGND VGND VPWR VPWR _4979_/A0 sky130_fd_sc_hd__dlygate4sd3_1
Xhold1033 _7194_/Q VGND VGND VPWR VPWR _5272_/A0 sky130_fd_sc_hd__dlygate4sd3_1
XFILLER_100_687 VGND VGND VPWR VPWR sky130_fd_sc_hd__decap_3
XFILLER_93_18 VGND VGND VPWR VPWR sky130_fd_sc_hd__decap_3
Xhold1044 _7186_/Q VGND VGND VPWR VPWR _5286_/A0 sky130_fd_sc_hd__dlygate4sd3_1
Xhold1055 _7208_/Q VGND VGND VPWR VPWR _5243_/A0 sky130_fd_sc_hd__dlygate4sd3_1
Xhold1066 _7271_/Q VGND VGND VPWR VPWR _4837_/A0 sky130_fd_sc_hd__dlygate4sd3_1
XFILLER_26_23 VGND VGND VPWR VPWR sky130_fd_sc_hd__decap_3
XFILLER_38_270 VGND VGND VPWR VPWR sky130_fd_sc_hd__decap_3
Xhold1077 _7323_/Q VGND VGND VPWR VPWR _4513_/A0 sky130_fd_sc_hd__dlygate4sd3_1
Xhold1088 _7219_/Q VGND VGND VPWR VPWR _5219_/A sky130_fd_sc_hd__dlygate4sd3_1
Xhold1099 _7295_/Q VGND VGND VPWR VPWR _4571_/A sky130_fd_sc_hd__dlygate4sd3_1
X_5019_ _4243_/Y _5032_/B _4989_/X _5018_/Y VGND VGND VPWR VPWR _5020_/B sky130_fd_sc_hd__a22o_2
XFILLER_26_454 VGND VGND VPWR VPWR sky130_fd_sc_hd__decap_3
XFILLER_14_616 VGND VGND VPWR VPWR sky130_fd_sc_hd__decap_3
XFILLER_26_67 VGND VGND VPWR VPWR sky130_fd_sc_hd__fill_2
XFILLER_41_402 VGND VGND VPWR VPWR sky130_fd_sc_hd__decap_3
XFILLER_53_273 VGND VGND VPWR VPWR sky130_fd_sc_hd__decap_3
XFILLER_53_284 VGND VGND VPWR VPWR sky130_fd_sc_hd__decap_3
XFILLER_81_582 VGND VGND VPWR VPWR sky130_fd_sc_hd__decap_3
XFILLER_22_660 VGND VGND VPWR VPWR sky130_fd_sc_hd__decap_3
XTAP_TAPCELL_ROW_101_1466 VGND VPWR sky130_fd_sc_hd__tapvpwrvgnd_1
XFILLER_107_297 VGND VGND VPWR VPWR sky130_fd_sc_hd__decap_3
XFILLER_1_520 VGND VGND VPWR VPWR sky130_fd_sc_hd__decap_3
XFILLER_1_553 VGND VGND VPWR VPWR sky130_fd_sc_hd__decap_3
XFILLER_96_619 VGND VGND VPWR VPWR sky130_fd_sc_hd__decap_3
XFILLER_107_70 VGND VGND VPWR VPWR sky130_fd_sc_hd__decap_3
XFILLER_1_586 VGND VGND VPWR VPWR sky130_fd_sc_hd__decap_3
XFILLER_89_671 VGND VGND VPWR VPWR sky130_fd_sc_hd__fill_1
XFILLER_89_682 VGND VGND VPWR VPWR sky130_fd_sc_hd__decap_3
XTAP_TAPCELL_ROW_112_1595 VGND VPWR sky130_fd_sc_hd__tapvpwrvgnd_1
XFILLER_103_492 VGND VGND VPWR VPWR sky130_fd_sc_hd__decap_3
XFILLER_67_52 VGND VGND VPWR VPWR sky130_fd_sc_hd__decap_3
XFILLER_88_192 VGND VGND VPWR VPWR sky130_fd_sc_hd__decap_3
XFILLER_49_579 VGND VGND VPWR VPWR sky130_fd_sc_hd__decap_3
XFILLER_67_96 VGND VGND VPWR VPWR sky130_fd_sc_hd__decap_3
XFILLER_29_270 VGND VGND VPWR VPWR sky130_fd_sc_hd__fill_2
XFILLER_29_281 VGND VGND VPWR VPWR sky130_fd_sc_hd__decap_3
XFILLER_36_218 VGND VGND VPWR VPWR sky130_fd_sc_hd__fill_2
XFILLER_44_240 VGND VGND VPWR VPWR sky130_fd_sc_hd__decap_3
XTAP_TAPCELL_ROW_67_1052 VGND VPWR sky130_fd_sc_hd__tapvpwrvgnd_1
XFILLER_44_262 VGND VGND VPWR VPWR sky130_fd_sc_hd__decap_3
XFILLER_44_273 VGND VGND VPWR VPWR sky130_fd_sc_hd__decap_3
XFILLER_72_571 VGND VGND VPWR VPWR sky130_fd_sc_hd__decap_3
XFILLER_83_73 VGND VGND VPWR VPWR sky130_fd_sc_hd__decap_3
XFILLER_13_671 VGND VGND VPWR VPWR sky130_fd_sc_hd__fill_1
XFILLER_20_619 VGND VGND VPWR VPWR sky130_fd_sc_hd__decap_3
XFILLER_9_620 VGND VGND VPWR VPWR sky130_fd_sc_hd__decap_3
XFILLER_12_181 VGND VGND VPWR VPWR sky130_fd_sc_hd__fill_2
XFILLER_13_682 VGND VGND VPWR VPWR sky130_fd_sc_hd__decap_3
XTAP_TAPCELL_ROW_30_614 VGND VPWR sky130_fd_sc_hd__tapvpwrvgnd_1
XFILLER_9_653 VGND VGND VPWR VPWR sky130_fd_sc_hd__decap_3
XFILLER_8_141 VGND VGND VPWR VPWR sky130_fd_sc_hd__decap_3
XFILLER_59_3 VGND VGND VPWR VPWR sky130_fd_sc_hd__decap_3
XTAP_TAPCELL_ROW_10_371 VGND VPWR sky130_fd_sc_hd__tapvpwrvgnd_1
X_4321_ _7098_/Q _4335_/B1 _4351_/B1 _7130_/Q VGND VGND VPWR VPWR _4321_/X sky130_fd_sc_hd__a22o_2
XTAP_TAPCELL_ROW_78_1192 VGND VPWR sky130_fd_sc_hd__tapvpwrvgnd_1
XFILLER_4_391 VGND VGND VPWR VPWR sky130_fd_sc_hd__decap_3
X_7040_ _7392_/CLK _7040_/D _6320_/Y VGND VGND VPWR VPWR _7040_/Q sky130_fd_sc_hd__dfrtp_2
X_4252_ _7197_/Q _3968_/S _4312_/B _7357_/Q VGND VGND VPWR VPWR _4252_/X sky130_fd_sc_hd__a22o_2
XFILLER_101_407 VGND VGND VPWR VPWR sky130_fd_sc_hd__decap_3
XFILLER_101_418 VGND VGND VPWR VPWR sky130_fd_sc_hd__decap_3
XFILLER_67_310 VGND VGND VPWR VPWR sky130_fd_sc_hd__decap_3
XFILLER_79_181 VGND VGND VPWR VPWR sky130_fd_sc_hd__decap_3
XFILLER_95_641 VGND VGND VPWR VPWR sky130_fd_sc_hd__decap_3
X_4183_ _7360_/Q _4312_/B _4267_/B1 _7168_/Q _4182_/X VGND VGND VPWR VPWR _4183_/X
+ sky130_fd_sc_hd__a221o_2
XFILLER_55_505 VGND VGND VPWR VPWR sky130_fd_sc_hd__fill_1
XFILLER_67_354 VGND VGND VPWR VPWR sky130_fd_sc_hd__decap_3
XFILLER_95_685 VGND VGND VPWR VPWR sky130_fd_sc_hd__decap_3
XTAP_TAPCELL_ROW_38_703 VGND VPWR sky130_fd_sc_hd__tapvpwrvgnd_1
XFILLER_67_398 VGND VGND VPWR VPWR sky130_fd_sc_hd__decap_3
XFILLER_82_324 VGND VGND VPWR VPWR sky130_fd_sc_hd__decap_3
XFILLER_94_184 VGND VGND VPWR VPWR sky130_fd_sc_hd__decap_3
XFILLER_35_240 VGND VGND VPWR VPWR sky130_fd_sc_hd__decap_3
XFILLER_82_346 VGND VGND VPWR VPWR sky130_fd_sc_hd__decap_3
XFILLER_63_582 VGND VGND VPWR VPWR sky130_fd_sc_hd__decap_3
XFILLER_35_284 VGND VGND VPWR VPWR sky130_fd_sc_hd__decap_3
X_6824_ _6954_/CLK _6824_/D VGND VGND VPWR VPWR _6824_/Q sky130_fd_sc_hd__dfxtp_2
XTAP_TAPCELL_ROW_18_471 VGND VPWR sky130_fd_sc_hd__tapvpwrvgnd_1
XFILLER_50_265 VGND VGND VPWR VPWR sky130_fd_sc_hd__fill_2
X_6755_ _6970_/CLK _6755_/D VGND VGND VPWR VPWR _6755_/Q sky130_fd_sc_hd__dfxtp_2
X_5706_ _7359_/Q hold939/X _5708_/S VGND VGND VPWR VPWR _6703_/D sky130_fd_sc_hd__mux2_2
XFILLER_109_529 VGND VGND VPWR VPWR sky130_fd_sc_hd__decap_3
Xclkbuf_leaf_30_clk clkload2/A VGND VGND VPWR VPWR _7355_/CLK sky130_fd_sc_hd__clkbuf_16
X_6686_ _6686_/A VGND VGND VPWR VPWR _6686_/Y sky130_fd_sc_hd__inv_2
X_3898_ _6919_/Q _3926_/A2 _3926_/B1 _6783_/Q VGND VGND VPWR VPWR _3898_/X sky130_fd_sc_hd__a22o_2
X_5568_ hold949/X _4960_/A _4897_/X VGND VGND VPWR VPWR _7049_/D sky130_fd_sc_hd__a21o_2
X_7307_ _7307_/CLK _7307_/D _6587_/Y VGND VGND VPWR VPWR _7307_/Q sky130_fd_sc_hd__dfrtp_2
X_4519_ hold977/X _3398_/Y _4300_/X VGND VGND VPWR VPWR _7320_/D sky130_fd_sc_hd__a21o_2
XFILLER_104_256 VGND VGND VPWR VPWR sky130_fd_sc_hd__decap_3
XFILLER_78_619 VGND VGND VPWR VPWR sky130_fd_sc_hd__decap_3
X_7238_ _7368_/CLK _7238_/D _6518_/Y VGND VGND VPWR VPWR _7238_/Q sky130_fd_sc_hd__dfrtp_2
XFILLER_104_289 VGND VGND VPWR VPWR sky130_fd_sc_hd__decap_3
X_7169_ _7365_/CLK _7169_/D _6449_/Y VGND VGND VPWR VPWR _7169_/Q sky130_fd_sc_hd__dfrtp_2
XFILLER_100_462 VGND VGND VPWR VPWR sky130_fd_sc_hd__fill_2
XFILLER_37_22 VGND VGND VPWR VPWR sky130_fd_sc_hd__decap_3
XFILLER_73_302 VGND VGND VPWR VPWR sky130_fd_sc_hd__decap_3
XFILLER_85_151 VGND VGND VPWR VPWR sky130_fd_sc_hd__fill_1
XFILLER_86_663 VGND VGND VPWR VPWR sky130_fd_sc_hd__decap_3
XFILLER_100_473 VGND VGND VPWR VPWR sky130_fd_sc_hd__decap_3
XFILLER_100_495 VGND VGND VPWR VPWR sky130_fd_sc_hd__decap_3
XFILLER_58_398 VGND VGND VPWR VPWR sky130_fd_sc_hd__decap_3
XFILLER_73_324 VGND VGND VPWR VPWR sky130_fd_sc_hd__decap_3
XFILLER_37_77 VGND VGND VPWR VPWR sky130_fd_sc_hd__decap_3
XFILLER_61_508 VGND VGND VPWR VPWR sky130_fd_sc_hd__decap_3
XFILLER_73_346 VGND VGND VPWR VPWR sky130_fd_sc_hd__decap_3
XFILLER_14_413 VGND VGND VPWR VPWR sky130_fd_sc_hd__decap_3
XFILLER_26_251 VGND VGND VPWR VPWR sky130_fd_sc_hd__fill_1
XFILLER_26_262 VGND VGND VPWR VPWR sky130_fd_sc_hd__decap_3
XFILLER_14_424 VGND VGND VPWR VPWR sky130_fd_sc_hd__decap_3
XFILLER_26_284 VGND VGND VPWR VPWR sky130_fd_sc_hd__decap_3
XFILLER_41_276 VGND VGND VPWR VPWR sky130_fd_sc_hd__decap_3
XFILLER_41_287 VGND VGND VPWR VPWR sky130_fd_sc_hd__decap_3
XFILLER_10_663 VGND VGND VPWR VPWR sky130_fd_sc_hd__decap_3
XFILLER_22_490 VGND VGND VPWR VPWR sky130_fd_sc_hd__decap_3
XFILLER_6_601 VGND VGND VPWR VPWR sky130_fd_sc_hd__decap_3
Xclkbuf_leaf_21_clk clkload5/A VGND VGND VPWR VPWR _7368_/CLK sky130_fd_sc_hd__clkbuf_16
XFILLER_5_111 VGND VGND VPWR VPWR sky130_fd_sc_hd__fill_1
XFILLER_5_122 VGND VGND VPWR VPWR sky130_fd_sc_hd__decap_3
XFILLER_6_634 VGND VGND VPWR VPWR sky130_fd_sc_hd__decap_3
XFILLER_6_645 VGND VGND VPWR VPWR sky130_fd_sc_hd__decap_3
XFILLER_108_551 VGND VGND VPWR VPWR sky130_fd_sc_hd__decap_3
XFILLER_6_678 VGND VGND VPWR VPWR sky130_fd_sc_hd__decap_3
XFILLER_108_584 VGND VGND VPWR VPWR sky130_fd_sc_hd__decap_3
XFILLER_108_595 VGND VGND VPWR VPWR sky130_fd_sc_hd__decap_3
XTAP_TAPCELL_ROW_114_1624 VGND VPWR sky130_fd_sc_hd__tapvpwrvgnd_1
XFILLER_5_199 VGND VGND VPWR VPWR sky130_fd_sc_hd__decap_3
XFILLER_110_204 VGND VGND VPWR VPWR sky130_fd_sc_hd__decap_3
XFILLER_78_73 VGND VGND VPWR VPWR sky130_fd_sc_hd__decap_3
XFILLER_49_332 VGND VGND VPWR VPWR sky130_fd_sc_hd__decap_3
XFILLER_77_641 VGND VGND VPWR VPWR sky130_fd_sc_hd__decap_3
XFILLER_49_343 VGND VGND VPWR VPWR sky130_fd_sc_hd__decap_3
XFILLER_49_365 VGND VGND VPWR VPWR sky130_fd_sc_hd__decap_3
XFILLER_49_376 VGND VGND VPWR VPWR sky130_fd_sc_hd__decap_3
XFILLER_64_335 VGND VGND VPWR VPWR sky130_fd_sc_hd__decap_3
XFILLER_77_685 VGND VGND VPWR VPWR sky130_fd_sc_hd__decap_3
XFILLER_92_622 VGND VGND VPWR VPWR sky130_fd_sc_hd__decap_3
XFILLER_52_508 VGND VGND VPWR VPWR sky130_fd_sc_hd__decap_3
XFILLER_64_368 VGND VGND VPWR VPWR sky130_fd_sc_hd__decap_3
XFILLER_91_143 VGND VGND VPWR VPWR sky130_fd_sc_hd__decap_3
XFILLER_92_666 VGND VGND VPWR VPWR sky130_fd_sc_hd__decap_3
XFILLER_17_240 VGND VGND VPWR VPWR sky130_fd_sc_hd__decap_3
XFILLER_17_262 VGND VGND VPWR VPWR sky130_fd_sc_hd__decap_3
XFILLER_45_582 VGND VGND VPWR VPWR sky130_fd_sc_hd__decap_3
XFILLER_60_530 VGND VGND VPWR VPWR sky130_fd_sc_hd__fill_2
XFILLER_60_541 VGND VGND VPWR VPWR sky130_fd_sc_hd__decap_3
XFILLER_72_390 VGND VGND VPWR VPWR sky130_fd_sc_hd__fill_2
X_4870_ _4870_/A _4870_/B VGND VGND VPWR VPWR _4870_/Y sky130_fd_sc_hd__nor2_2
X_3821_ _3746_/C _3819_/X _3820_/X _3904_/A VGND VGND VPWR VPWR _5010_/C sky130_fd_sc_hd__o31a_2
XTAP_TAPCELL_ROW_15_430 VGND VPWR sky130_fd_sc_hd__tapvpwrvgnd_1
XFILLER_20_449 VGND VGND VPWR VPWR sky130_fd_sc_hd__decap_3
XFILLER_32_298 VGND VGND VPWR VPWR sky130_fd_sc_hd__decap_3
XFILLER_60_585 VGND VGND VPWR VPWR sky130_fd_sc_hd__decap_3
X_6540_ _6637_/A VGND VGND VPWR VPWR _6540_/Y sky130_fd_sc_hd__inv_2
XTAP_TAPCELL_ROW_43_772 VGND VPWR sky130_fd_sc_hd__tapvpwrvgnd_1
Xclkbuf_leaf_12_clk clkbuf_leaf_9_clk/A VGND VGND VPWR VPWR _7405_/CLK sky130_fd_sc_hd__clkbuf_16
X_3752_ _6799_/Q _3918_/B1 _3917_/A2 _6709_/Q _3751_/X VGND VGND VPWR VPWR _3752_/X
+ sky130_fd_sc_hd__a221o_2
X_6471_ _6624_/A VGND VGND VPWR VPWR _6471_/Y sky130_fd_sc_hd__inv_2
X_3683_ _3672_/X _3673_/X _3904_/A _3682_/Y VGND VGND VPWR VPWR _3683_/Y sky130_fd_sc_hd__o211ai_2
XFILLER_9_483 VGND VGND VPWR VPWR sky130_fd_sc_hd__decap_3
XFILLER_114_510 VGND VGND VPWR VPWR sky130_fd_sc_hd__decap_3
XFILLER_114_554 VGND VGND VPWR VPWR sky130_fd_sc_hd__decap_3
X_4304_ _7256_/Q _4601_/S _4303_/X VGND VGND VPWR VPWR _4364_/A sky130_fd_sc_hd__a21oi_2
XFILLER_114_587 VGND VGND VPWR VPWR sky130_fd_sc_hd__fill_1
XFILLER_87_405 VGND VGND VPWR VPWR sky130_fd_sc_hd__decap_3
X_5284_ _5284_/A0 _5135_/X _5292_/S VGND VGND VPWR VPWR _7187_/D sky130_fd_sc_hd__mux2_2
XFILLER_114_598 VGND VGND VPWR VPWR sky130_fd_sc_hd__decap_3
XFILLER_87_449 VGND VGND VPWR VPWR sky130_fd_sc_hd__decap_3
X_7023_ _7365_/CLK _7023_/D _6303_/Y VGND VGND VPWR VPWR _7023_/Q sky130_fd_sc_hd__dfrtp_2
X_4235_ _7227_/Q _4349_/B1 _4348_/B1 _7131_/Q VGND VGND VPWR VPWR _4235_/X sky130_fd_sc_hd__a22o_2
XFILLER_114_27 VGND VGND VPWR VPWR sky130_fd_sc_hd__fill_1
XFILLER_114_38 VGND VGND VPWR VPWR sky130_fd_sc_hd__decap_3
XFILLER_68_663 VGND VGND VPWR VPWR sky130_fd_sc_hd__decap_3
XFILLER_83_600 VGND VGND VPWR VPWR sky130_fd_sc_hd__decap_3
X_4166_ _7233_/Q _4414_/A2 _4390_/B1 _7201_/Q VGND VGND VPWR VPWR _4166_/X sky130_fd_sc_hd__a22o_2
XFILLER_55_313 VGND VGND VPWR VPWR sky130_fd_sc_hd__decap_3
XFILLER_43_508 VGND VGND VPWR VPWR sky130_fd_sc_hd__decap_3
XFILLER_83_644 VGND VGND VPWR VPWR sky130_fd_sc_hd__decap_3
XFILLER_36_560 VGND VGND VPWR VPWR sky130_fd_sc_hd__decap_3
XFILLER_70_327 VGND VGND VPWR VPWR sky130_fd_sc_hd__fill_1
XFILLER_82_176 VGND VGND VPWR VPWR sky130_fd_sc_hd__decap_3
XFILLER_83_688 VGND VGND VPWR VPWR sky130_fd_sc_hd__decap_3
XFILLER_11_405 VGND VGND VPWR VPWR sky130_fd_sc_hd__decap_3
Xplace390 _4671_/B VGND VGND VPWR VPWR _5633_/B sky130_fd_sc_hd__buf_2
X_6807_ _6941_/CLK _6807_/D VGND VGND VPWR VPWR _6807_/Q sky130_fd_sc_hd__dfxtp_2
XFILLER_23_276 VGND VGND VPWR VPWR sky130_fd_sc_hd__decap_3
XFILLER_51_585 VGND VGND VPWR VPWR sky130_fd_sc_hd__decap_3
XFILLER_11_449 VGND VGND VPWR VPWR sky130_fd_sc_hd__decap_3
XFILLER_23_68 VGND VGND VPWR VPWR sky130_fd_sc_hd__fill_1
XFILLER_7_409 VGND VGND VPWR VPWR sky130_fd_sc_hd__decap_3
X_6738_ _6978_/CLK _6738_/D VGND VGND VPWR VPWR _6738_/Q sky130_fd_sc_hd__dfxtp_2
X_6669_ _6672_/A VGND VGND VPWR VPWR _6669_/Y sky130_fd_sc_hd__inv_2
XTAP_TAPCELL_ROW_21_499 VGND VPWR sky130_fd_sc_hd__tapvpwrvgnd_1
XFILLER_3_615 VGND VGND VPWR VPWR sky130_fd_sc_hd__fill_1
XFILLER_3_626 VGND VGND VPWR VPWR sky130_fd_sc_hd__decap_3
XFILLER_105_532 VGND VGND VPWR VPWR sky130_fd_sc_hd__decap_3
XFILLER_3_659 VGND VGND VPWR VPWR sky130_fd_sc_hd__decap_3
XFILLER_105_576 VGND VGND VPWR VPWR sky130_fd_sc_hd__decap_3
XFILLER_78_427 VGND VGND VPWR VPWR sky130_fd_sc_hd__fill_2
XFILLER_59_641 VGND VGND VPWR VPWR sky130_fd_sc_hd__decap_3
XFILLER_46_302 VGND VGND VPWR VPWR sky130_fd_sc_hd__decap_3
XFILLER_58_162 VGND VGND VPWR VPWR sky130_fd_sc_hd__fill_1
XFILLER_59_685 VGND VGND VPWR VPWR sky130_fd_sc_hd__decap_3
XFILLER_74_622 VGND VGND VPWR VPWR sky130_fd_sc_hd__decap_3
XFILLER_19_549 VGND VGND VPWR VPWR sky130_fd_sc_hd__decap_3
XFILLER_46_335 VGND VGND VPWR VPWR sky130_fd_sc_hd__decap_3
XFILLER_64_20 VGND VGND VPWR VPWR sky130_fd_sc_hd__decap_3
XFILLER_74_666 VGND VGND VPWR VPWR sky130_fd_sc_hd__decap_3
XFILLER_61_305 VGND VGND VPWR VPWR sky130_fd_sc_hd__decap_3
XFILLER_73_165 VGND VGND VPWR VPWR sky130_fd_sc_hd__decap_3
XFILLER_14_221 VGND VGND VPWR VPWR sky130_fd_sc_hd__decap_3
XFILLER_27_582 VGND VGND VPWR VPWR sky130_fd_sc_hd__decap_3
XTAP_TAPCELL_ROW_64_1022 VGND VPWR sky130_fd_sc_hd__tapvpwrvgnd_1
XTAP_TAPCELL_ROW_29_599 VGND VPWR sky130_fd_sc_hd__tapvpwrvgnd_1
XFILLER_14_232 VGND VGND VPWR VPWR sky130_fd_sc_hd__fill_1
XFILLER_42_563 VGND VGND VPWR VPWR sky130_fd_sc_hd__decap_3
XFILLER_14_298 VGND VGND VPWR VPWR sky130_fd_sc_hd__decap_3
XTAP_TAPCELL_ROW_12_400 VGND VPWR sky130_fd_sc_hd__tapvpwrvgnd_1
XTAP_TAPCELL_ROW_40_731 VGND VPWR sky130_fd_sc_hd__tapvpwrvgnd_1
XFILLER_80_85 VGND VGND VPWR VPWR sky130_fd_sc_hd__decap_3
XFILLER_108_392 VGND VGND VPWR VPWR sky130_fd_sc_hd__fill_2
XFILLER_89_94 VGND VGND VPWR VPWR sky130_fd_sc_hd__decap_3
XTAP_TAPCELL_ROW_75_1151 VGND VPWR sky130_fd_sc_hd__tapvpwrvgnd_1
XFILLER_69_427 VGND VGND VPWR VPWR sky130_fd_sc_hd__fill_1
XFILLER_111_535 VGND VGND VPWR VPWR sky130_fd_sc_hd__decap_3
XFILLER_2_681 VGND VGND VPWR VPWR sky130_fd_sc_hd__decap_3
XFILLER_69_449 VGND VGND VPWR VPWR sky130_fd_sc_hd__fill_2
XFILLER_96_224 VGND VGND VPWR VPWR sky130_fd_sc_hd__fill_2
XFILLER_111_579 VGND VGND VPWR VPWR sky130_fd_sc_hd__decap_3
XFILLER_1_180 VGND VGND VPWR VPWR sky130_fd_sc_hd__decap_3
XFILLER_65_600 VGND VGND VPWR VPWR sky130_fd_sc_hd__decap_3
XFILLER_84_408 VGND VGND VPWR VPWR sky130_fd_sc_hd__decap_3
Xclkbuf_leaf_1_clk clkbuf_leaf_1_clk/A VGND VGND VPWR VPWR clkload6/A sky130_fd_sc_hd__clkbuf_16
X_4020_ _7086_/Q _4102_/B _4432_/B1 _4019_/X VGND VGND VPWR VPWR _4039_/A sky130_fd_sc_hd__o211ai_2
XFILLER_37_313 VGND VGND VPWR VPWR sky130_fd_sc_hd__decap_3
XFILLER_77_471 VGND VGND VPWR VPWR sky130_fd_sc_hd__decap_3
XFILLER_65_644 VGND VGND VPWR VPWR sky130_fd_sc_hd__decap_3
XFILLER_92_430 VGND VGND VPWR VPWR sky130_fd_sc_hd__decap_3
XTAP_TAPCELL_ROW_48_831 VGND VPWR sky130_fd_sc_hd__tapvpwrvgnd_1
XFILLER_18_560 VGND VGND VPWR VPWR sky130_fd_sc_hd__decap_3
XFILLER_64_176 VGND VGND VPWR VPWR sky130_fd_sc_hd__decap_3
XFILLER_65_688 VGND VGND VPWR VPWR sky130_fd_sc_hd__decap_3
XFILLER_80_625 VGND VGND VPWR VPWR sky130_fd_sc_hd__decap_3
XFILLER_52_349 VGND VGND VPWR VPWR sky130_fd_sc_hd__decap_3
XFILLER_80_669 VGND VGND VPWR VPWR sky130_fd_sc_hd__decap_3
X_4922_ _4937_/A _4937_/B _4203_/X VGND VGND VPWR VPWR _4922_/X sky130_fd_sc_hd__a21o_2
XTAP_TAPCELL_ROW_86_1280 VGND VPWR sky130_fd_sc_hd__tapvpwrvgnd_1
XFILLER_100_18 VGND VGND VPWR VPWR sky130_fd_sc_hd__decap_3
XFILLER_100_29 VGND VGND VPWR VPWR sky130_fd_sc_hd__fill_1
XFILLER_33_585 VGND VGND VPWR VPWR sky130_fd_sc_hd__decap_3
XFILLER_60_371 VGND VGND VPWR VPWR sky130_fd_sc_hd__decap_3
XFILLER_60_382 VGND VGND VPWR VPWR sky130_fd_sc_hd__decap_3
XFILLER_20_246 VGND VGND VPWR VPWR sky130_fd_sc_hd__decap_3
X_4784_ _4813_/A _4829_/B VGND VGND VPWR VPWR _4811_/B sky130_fd_sc_hd__nand2_2
X_3804_ _6826_/Q _3879_/A2 _3878_/A2 _6811_/Q _3803_/X VGND VGND VPWR VPWR _3804_/X
+ sky130_fd_sc_hd__a221o_2
X_6523_ _6620_/A VGND VGND VPWR VPWR _6523_/Y sky130_fd_sc_hd__inv_2
X_3735_ _3735_/A _3746_/B _3746_/C VGND VGND VPWR VPWR _3735_/X sky130_fd_sc_hd__and3_4
XFILLER_109_38 VGND VGND VPWR VPWR sky130_fd_sc_hd__decap_3
X_6454_ _6614_/A VGND VGND VPWR VPWR _6454_/Y sky130_fd_sc_hd__inv_2
XFILLER_9_291 VGND VGND VPWR VPWR sky130_fd_sc_hd__fill_1
X_6385_ _6618_/A VGND VGND VPWR VPWR _6385_/Y sky130_fd_sc_hd__inv_2
X_3597_ _4295_/B _3607_/B VGND VGND VPWR VPWR _3611_/B sky130_fd_sc_hd__nor2_2
XFILLER_102_513 VGND VGND VPWR VPWR sky130_fd_sc_hd__decap_3
XFILLER_114_351 VGND VGND VPWR VPWR sky130_fd_sc_hd__fill_1
XFILLER_114_362 VGND VGND VPWR VPWR sky130_fd_sc_hd__fill_2
X_5336_ _5336_/A0 _5040_/X _5354_/S VGND VGND VPWR VPWR _7163_/D sky130_fd_sc_hd__mux2_2
XFILLER_114_395 VGND VGND VPWR VPWR sky130_fd_sc_hd__decap_3
XFILLER_102_557 VGND VGND VPWR VPWR sky130_fd_sc_hd__decap_3
X_7006_ _7374_/CLK _7006_/D _6286_/Y VGND VGND VPWR VPWR _7006_/Q sky130_fd_sc_hd__dfrtp_2
X_4218_ _7100_/Q _4335_/B1 _4267_/A2 _7132_/Q VGND VGND VPWR VPWR _4218_/X sky130_fd_sc_hd__a22o_2
XFILLER_18_24 VGND VGND VPWR VPWR sky130_fd_sc_hd__decap_3
XFILLER_56_622 VGND VGND VPWR VPWR sky130_fd_sc_hd__decap_3
X_5198_ _5198_/A _5209_/B VGND VGND VPWR VPWR _7229_/D sky130_fd_sc_hd__and2_2
XFILLER_18_68 VGND VGND VPWR VPWR sky130_fd_sc_hd__decap_3
XFILLER_28_335 VGND VGND VPWR VPWR sky130_fd_sc_hd__decap_3
XFILLER_28_346 VGND VGND VPWR VPWR sky130_fd_sc_hd__decap_3
XFILLER_55_121 VGND VGND VPWR VPWR sky130_fd_sc_hd__decap_3
XFILLER_56_666 VGND VGND VPWR VPWR sky130_fd_sc_hd__decap_3
X_4149_ _4205_/A _4205_/B VGND VGND VPWR VPWR _4157_/A sky130_fd_sc_hd__nand2_2
XFILLER_28_368 VGND VGND VPWR VPWR sky130_fd_sc_hd__fill_1
XFILLER_28_379 VGND VGND VPWR VPWR sky130_fd_sc_hd__fill_1
XFILLER_43_305 VGND VGND VPWR VPWR sky130_fd_sc_hd__decap_3
XFILLER_55_154 VGND VGND VPWR VPWR sky130_fd_sc_hd__fill_2
XFILLER_55_165 VGND VGND VPWR VPWR sky130_fd_sc_hd__decap_3
XFILLER_71_603 VGND VGND VPWR VPWR sky130_fd_sc_hd__decap_3
XFILLER_83_463 VGND VGND VPWR VPWR sky130_fd_sc_hd__decap_3
XFILLER_70_135 VGND VGND VPWR VPWR sky130_fd_sc_hd__decap_3
XFILLER_71_647 VGND VGND VPWR VPWR sky130_fd_sc_hd__decap_3
XFILLER_24_563 VGND VGND VPWR VPWR sky130_fd_sc_hd__decap_3
XFILLER_70_157 VGND VGND VPWR VPWR sky130_fd_sc_hd__decap_3
XTAP_TAPCELL_ROW_26_569 VGND VPWR sky130_fd_sc_hd__tapvpwrvgnd_1
XTAP_TAPCELL_ROW_26_558 VGND VPWR sky130_fd_sc_hd__tapvpwrvgnd_1
XFILLER_34_78 VGND VGND VPWR VPWR sky130_fd_sc_hd__decap_3
XFILLER_51_393 VGND VGND VPWR VPWR sky130_fd_sc_hd__decap_3
XFILLER_11_268 VGND VGND VPWR VPWR sky130_fd_sc_hd__decap_3
XFILLER_7_228 VGND VGND VPWR VPWR sky130_fd_sc_hd__decap_3
Xclkload0 clkload0/A VGND VGND VPWR VPWR clkload0/X sky130_fd_sc_hd__clkbuf_16
XFILLER_50_88 VGND VGND VPWR VPWR sky130_fd_sc_hd__decap_3
XFILLER_105_340 VGND VGND VPWR VPWR sky130_fd_sc_hd__fill_1
XFILLER_105_362 VGND VGND VPWR VPWR sky130_fd_sc_hd__decap_3
XFILLER_3_456 VGND VGND VPWR VPWR sky130_fd_sc_hd__decap_3
XFILLER_3_478 VGND VGND VPWR VPWR sky130_fd_sc_hd__decap_3
XFILLER_59_75 VGND VGND VPWR VPWR sky130_fd_sc_hd__decap_3
XFILLER_78_268 VGND VGND VPWR VPWR sky130_fd_sc_hd__decap_3
XFILLER_115_81 VGND VGND VPWR VPWR sky130_fd_sc_hd__decap_3
XFILLER_19_302 VGND VGND VPWR VPWR sky130_fd_sc_hd__decap_3
XFILLER_47_600 VGND VGND VPWR VPWR sky130_fd_sc_hd__decap_3
XFILLER_93_205 VGND VGND VPWR VPWR sky130_fd_sc_hd__decap_3
XTAP_TAPCELL_ROW_70_1092 VGND VPWR sky130_fd_sc_hd__tapvpwrvgnd_1
XFILLER_47_644 VGND VGND VPWR VPWR sky130_fd_sc_hd__decap_3
XFILLER_47_688 VGND VGND VPWR VPWR sky130_fd_sc_hd__decap_3
XFILLER_62_625 VGND VGND VPWR VPWR sky130_fd_sc_hd__decap_3
XFILLER_74_485 VGND VGND VPWR VPWR sky130_fd_sc_hd__decap_3
XFILLER_75_85 VGND VGND VPWR VPWR sky130_fd_sc_hd__decap_3
XFILLER_75_96 VGND VGND VPWR VPWR sky130_fd_sc_hd__decap_3
XTAP_TAPCELL_ROW_109_1556 VGND VPWR sky130_fd_sc_hd__tapvpwrvgnd_1
XFILLER_61_124 VGND VGND VPWR VPWR sky130_fd_sc_hd__decap_3
XFILLER_15_541 VGND VGND VPWR VPWR sky130_fd_sc_hd__decap_3
XFILLER_27_390 VGND VGND VPWR VPWR sky130_fd_sc_hd__fill_2
XFILLER_61_146 VGND VGND VPWR VPWR sky130_fd_sc_hd__decap_3
XFILLER_62_669 VGND VGND VPWR VPWR sky130_fd_sc_hd__decap_3
XFILLER_15_585 VGND VGND VPWR VPWR sky130_fd_sc_hd__decap_3
XFILLER_30_511 VGND VGND VPWR VPWR sky130_fd_sc_hd__decap_3
XFILLER_42_371 VGND VGND VPWR VPWR sky130_fd_sc_hd__fill_1
XFILLER_30_533 VGND VGND VPWR VPWR sky130_fd_sc_hd__fill_1
X_3520_ _5118_/D _3354_/X _3519_/Y _3350_/B VGND VGND VPWR VPWR _3525_/B sky130_fd_sc_hd__o2bb2a_2
Xhold707 _6851_/Q VGND VGND VPWR VPWR _6851_/D sky130_fd_sc_hd__dlygate4sd3_1
Xhold718 _6897_/Q VGND VGND VPWR VPWR _6897_/D sky130_fd_sc_hd__dlygate4sd3_1
XFILLER_115_137 VGND VGND VPWR VPWR sky130_fd_sc_hd__decap_3
XFILLER_6_294 VGND VGND VPWR VPWR sky130_fd_sc_hd__decap_3
Xhold729 _6733_/Q VGND VGND VPWR VPWR _6733_/D sky130_fd_sc_hd__dlygate4sd3_1
XFILLER_69_202 VGND VGND VPWR VPWR sky130_fd_sc_hd__decap_3
XFILLER_97_500 VGND VGND VPWR VPWR sky130_fd_sc_hd__decap_3
XFILLER_97_511 VGND VGND VPWR VPWR sky130_fd_sc_hd__decap_3
XFILLER_111_321 VGND VGND VPWR VPWR sky130_fd_sc_hd__decap_3
XFILLER_97_544 VGND VGND VPWR VPWR sky130_fd_sc_hd__decap_3
X_5121_ _4606_/Y _5117_/X _5118_/X _6984_/D _5666_/A VGND VGND VPWR VPWR _5121_/X
+ sky130_fd_sc_hd__a32o_2
XFILLER_69_257 VGND VGND VPWR VPWR sky130_fd_sc_hd__decap_3
XFILLER_38_622 VGND VGND VPWR VPWR sky130_fd_sc_hd__decap_3
XFILLER_97_588 VGND VGND VPWR VPWR sky130_fd_sc_hd__decap_3
X_5052_ _3548_/X _5049_/X _5051_/X _3618_/X VGND VGND VPWR VPWR _5052_/X sky130_fd_sc_hd__a2bb2o_2
XFILLER_65_430 VGND VGND VPWR VPWR sky130_fd_sc_hd__decap_3
XFILLER_84_249 VGND VGND VPWR VPWR sky130_fd_sc_hd__decap_3
XFILLER_38_666 VGND VGND VPWR VPWR sky130_fd_sc_hd__decap_3
XFILLER_53_603 VGND VGND VPWR VPWR sky130_fd_sc_hd__decap_3
XFILLER_65_452 VGND VGND VPWR VPWR sky130_fd_sc_hd__decap_3
XFILLER_53_647 VGND VGND VPWR VPWR sky130_fd_sc_hd__decap_3
XFILLER_65_485 VGND VGND VPWR VPWR sky130_fd_sc_hd__decap_3
XFILLER_92_293 VGND VGND VPWR VPWR sky130_fd_sc_hd__decap_3
XFILLER_111_39 VGND VGND VPWR VPWR sky130_fd_sc_hd__decap_3
XFILLER_33_360 VGND VGND VPWR VPWR sky130_fd_sc_hd__decap_3
X_4905_ _4970_/A1 _4888_/A _4903_/A _5101_/A VGND VGND VPWR VPWR _4905_/X sky130_fd_sc_hd__o2bb2a_2
XTAP_TAPCELL_ROW_23_528 VGND VPWR sky130_fd_sc_hd__tapvpwrvgnd_1
XFILLER_21_544 VGND VGND VPWR VPWR sky130_fd_sc_hd__decap_3
X_4836_ _7001_/D _4835_/X _5040_/S VGND VGND VPWR VPWR _4836_/X sky130_fd_sc_hd__mux2_2
XTAP_TAPCELL_ROW_51_859 VGND VPWR sky130_fd_sc_hd__tapvpwrvgnd_1
XFILLER_21_588 VGND VGND VPWR VPWR sky130_fd_sc_hd__decap_3
X_6506_ _6569_/A VGND VGND VPWR VPWR _6506_/Y sky130_fd_sc_hd__inv_2
X_4767_ _5057_/A _4452_/A _4453_/A _4852_/A _4766_/Y VGND VGND VPWR VPWR _4767_/X
+ sky130_fd_sc_hd__o221a_2
XFILLER_107_638 VGND VGND VPWR VPWR sky130_fd_sc_hd__decap_3
XFILLER_112_9 VGND VGND VPWR VPWR sky130_fd_sc_hd__decap_3
X_4698_ _6985_/Q _5120_/A VGND VGND VPWR VPWR _5098_/A sky130_fd_sc_hd__and2_2
X_6437_ _6596_/A VGND VGND VPWR VPWR _6437_/Y sky130_fd_sc_hd__inv_2
XFILLER_115_671 VGND VGND VPWR VPWR sky130_fd_sc_hd__fill_1
X_6368_ _6566_/A VGND VGND VPWR VPWR _6368_/Y sky130_fd_sc_hd__inv_2
XFILLER_0_437 VGND VGND VPWR VPWR sky130_fd_sc_hd__fill_2
XFILLER_115_682 VGND VGND VPWR VPWR sky130_fd_sc_hd__decap_3
XFILLER_88_522 VGND VGND VPWR VPWR sky130_fd_sc_hd__decap_3
XFILLER_88_533 VGND VGND VPWR VPWR sky130_fd_sc_hd__decap_3
XFILLER_96_18 VGND VGND VPWR VPWR sky130_fd_sc_hd__fill_1
XFILLER_96_29 VGND VGND VPWR VPWR sky130_fd_sc_hd__decap_3
X_5319_ _5319_/A0 _4913_/X _5323_/S VGND VGND VPWR VPWR _7171_/D sky130_fd_sc_hd__mux2_2
XFILLER_102_354 VGND VGND VPWR VPWR sky130_fd_sc_hd__decap_3
XFILLER_88_566 VGND VGND VPWR VPWR sky130_fd_sc_hd__decap_3
X_6299_ _6680_/A VGND VGND VPWR VPWR _6299_/Y sky130_fd_sc_hd__inv_2
XFILLER_29_600 VGND VGND VPWR VPWR sky130_fd_sc_hd__decap_3
XFILLER_102_398 VGND VGND VPWR VPWR sky130_fd_sc_hd__decap_3
XFILLER_29_644 VGND VGND VPWR VPWR sky130_fd_sc_hd__decap_3
XTAP_TAPCELL_ROW_59_959 VGND VPWR sky130_fd_sc_hd__tapvpwrvgnd_1
XFILLER_28_165 VGND VGND VPWR VPWR sky130_fd_sc_hd__fill_2
XFILLER_29_688 VGND VGND VPWR VPWR sky130_fd_sc_hd__decap_3
XFILLER_56_474 VGND VGND VPWR VPWR sky130_fd_sc_hd__fill_2
XFILLER_71_400 VGND VGND VPWR VPWR sky130_fd_sc_hd__decap_3
XFILLER_83_260 VGND VGND VPWR VPWR sky130_fd_sc_hd__decap_3
XTAP_TAPCELL_ROW_3_286 VGND VPWR sky130_fd_sc_hd__tapvpwrvgnd_1
XFILLER_43_102 VGND VGND VPWR VPWR sky130_fd_sc_hd__fill_2
XFILLER_43_124 VGND VGND VPWR VPWR sky130_fd_sc_hd__fill_2
XFILLER_44_625 VGND VGND VPWR VPWR sky130_fd_sc_hd__decap_3
XFILLER_71_411 VGND VGND VPWR VPWR sky130_fd_sc_hd__fill_1
XFILLER_44_669 VGND VGND VPWR VPWR sky130_fd_sc_hd__decap_3
XFILLER_71_444 VGND VGND VPWR VPWR sky130_fd_sc_hd__decap_3
XFILLER_71_455 VGND VGND VPWR VPWR sky130_fd_sc_hd__decap_3
XFILLER_24_371 VGND VGND VPWR VPWR sky130_fd_sc_hd__decap_3
XFILLER_71_488 VGND VGND VPWR VPWR sky130_fd_sc_hd__decap_3
XFILLER_12_533 VGND VGND VPWR VPWR sky130_fd_sc_hd__decap_3
XFILLER_61_21 VGND VGND VPWR VPWR sky130_fd_sc_hd__decap_3
XTAP_TAPCELL_ROW_104_1497 VGND VPWR sky130_fd_sc_hd__tapvpwrvgnd_1
XFILLER_12_566 VGND VGND VPWR VPWR sky130_fd_sc_hd__decap_3
XFILLER_8_548 VGND VGND VPWR VPWR sky130_fd_sc_hd__decap_3
XANTENNA_9 _4394_/A VGND VGND VPWR VPWR sky130_fd_sc_hd__diode_2
XFILLER_3_220 VGND VGND VPWR VPWR sky130_fd_sc_hd__decap_3
XFILLER_106_660 VGND VGND VPWR VPWR sky130_fd_sc_hd__decap_3
XFILLER_3_242 VGND VGND VPWR VPWR sky130_fd_sc_hd__fill_2
XTAP_TAPCELL_ROW_72_1110 VGND VPWR sky130_fd_sc_hd__tapvpwrvgnd_1
XFILLER_10_91 VGND VGND VPWR VPWR sky130_fd_sc_hd__fill_1
XFILLER_79_533 VGND VGND VPWR VPWR sky130_fd_sc_hd__decap_3
XTAP_TAPCELL_ROW_72_1121 VGND VPWR sky130_fd_sc_hd__tapvpwrvgnd_1
XFILLER_66_227 VGND VGND VPWR VPWR sky130_fd_sc_hd__decap_3
XFILLER_79_588 VGND VGND VPWR VPWR sky130_fd_sc_hd__decap_3
XFILLER_94_503 VGND VGND VPWR VPWR sky130_fd_sc_hd__decap_3
XFILLER_94_536 VGND VGND VPWR VPWR sky130_fd_sc_hd__decap_3
XFILLER_59_290 VGND VGND VPWR VPWR sky130_fd_sc_hd__decap_3
XFILLER_94_569 VGND VGND VPWR VPWR sky130_fd_sc_hd__decap_3
XFILLER_19_154 VGND VGND VPWR VPWR sky130_fd_sc_hd__decap_3
XFILLER_35_603 VGND VGND VPWR VPWR sky130_fd_sc_hd__decap_3
XFILLER_47_452 VGND VGND VPWR VPWR sky130_fd_sc_hd__decap_3
XFILLER_62_400 VGND VGND VPWR VPWR sky130_fd_sc_hd__decap_3
XFILLER_81_208 VGND VGND VPWR VPWR sky130_fd_sc_hd__decap_3
XFILLER_19_198 VGND VGND VPWR VPWR sky130_fd_sc_hd__decap_3
XFILLER_35_647 VGND VGND VPWR VPWR sky130_fd_sc_hd__decap_3
XFILLER_47_485 VGND VGND VPWR VPWR sky130_fd_sc_hd__decap_3
XFILLER_62_433 VGND VGND VPWR VPWR sky130_fd_sc_hd__decap_3
XFILLER_74_271 VGND VGND VPWR VPWR sky130_fd_sc_hd__decap_3
XFILLER_34_168 VGND VGND VPWR VPWR sky130_fd_sc_hd__decap_3
XFILLER_50_628 VGND VGND VPWR VPWR sky130_fd_sc_hd__decap_3
XFILLER_62_477 VGND VGND VPWR VPWR sky130_fd_sc_hd__decap_3
XTAP_TAPCELL_ROW_83_1250 VGND VPWR sky130_fd_sc_hd__tapvpwrvgnd_1
XFILLER_15_393 VGND VGND VPWR VPWR sky130_fd_sc_hd__decap_3
X_5670_ _5670_/A _5670_/B VGND VGND VPWR VPWR _5671_/B sky130_fd_sc_hd__nand2_2
XFILLER_89_3 VGND VGND VPWR VPWR sky130_fd_sc_hd__decap_3
X_4621_ _4315_/B _4343_/X _4315_/A VGND VGND VPWR VPWR _4621_/X sky130_fd_sc_hd__a21bo_2
XFILLER_116_402 VGND VGND VPWR VPWR sky130_fd_sc_hd__fill_1
X_7340_ _7372_/CLK _7340_/D _6620_/Y VGND VGND VPWR VPWR _7340_/Q sky130_fd_sc_hd__dfrtp_2
X_4552_ _4552_/A _4563_/B VGND VGND VPWR VPWR _7304_/D sky130_fd_sc_hd__and2_2
XFILLER_116_424 VGND VGND VPWR VPWR sky130_fd_sc_hd__fill_1
XFILLER_7_570 VGND VGND VPWR VPWR sky130_fd_sc_hd__decap_3
X_7271_ _7307_/CLK _7271_/D _6551_/Y VGND VGND VPWR VPWR _7271_/Q sky130_fd_sc_hd__dfrtp_2
X_3503_ _3545_/A _3545_/B VGND VGND VPWR VPWR _3630_/A sky130_fd_sc_hd__xor2_4
XFILLER_104_619 VGND VGND VPWR VPWR sky130_fd_sc_hd__decap_3
XFILLER_116_457 VGND VGND VPWR VPWR sky130_fd_sc_hd__decap_3
X_3434_ _7218_/Q _4349_/B1 _4348_/B1 _7122_/Q VGND VGND VPWR VPWR _3434_/X sky130_fd_sc_hd__a22o_2
XFILLER_106_17 VGND VGND VPWR VPWR sky130_fd_sc_hd__decap_3
XFILLER_112_663 VGND VGND VPWR VPWR sky130_fd_sc_hd__decap_3
XFILLER_97_352 VGND VGND VPWR VPWR sky130_fd_sc_hd__fill_2
X_3365_ _3365_/A VGND VGND VPWR VPWR _5118_/A sky130_fd_sc_hd__inv_2
XFILLER_111_140 VGND VGND VPWR VPWR sky130_fd_sc_hd__decap_3
XFILLER_57_216 VGND VGND VPWR VPWR sky130_fd_sc_hd__decap_3
Xhold1204 _7150_/Q VGND VGND VPWR VPWR _5365_/A0 sky130_fd_sc_hd__dlygate4sd3_1
Xhold1215 _7182_/Q VGND VGND VPWR VPWR _5296_/A0 sky130_fd_sc_hd__dlygate4sd3_1
X_5104_ _5104_/A _5660_/C VGND VGND VPWR VPWR _5104_/Y sky130_fd_sc_hd__nand2_2
XFILLER_85_536 VGND VGND VPWR VPWR sky130_fd_sc_hd__decap_3
XFILLER_97_396 VGND VGND VPWR VPWR sky130_fd_sc_hd__decap_3
Xhold1226 _7324_/Q VGND VGND VPWR VPWR _4510_/A0 sky130_fd_sc_hd__dlygate4sd3_1
XFILLER_38_463 VGND VGND VPWR VPWR sky130_fd_sc_hd__decap_3
XTAP_TAPCELL_ROW_56_929 VGND VPWR sky130_fd_sc_hd__tapvpwrvgnd_1
XTAP_TAPCELL_ROW_56_918 VGND VPWR sky130_fd_sc_hd__tapvpwrvgnd_1
XFILLER_25_113 VGND VGND VPWR VPWR sky130_fd_sc_hd__fill_2
XFILLER_26_625 VGND VGND VPWR VPWR sky130_fd_sc_hd__decap_3
XFILLER_53_422 VGND VGND VPWR VPWR sky130_fd_sc_hd__fill_2
XFILLER_93_591 VGND VGND VPWR VPWR sky130_fd_sc_hd__decap_3
XTAP_TAPCELL_ROW_0_245 VGND VPWR sky130_fd_sc_hd__tapvpwrvgnd_1
XTAP_TAPCELL_ROW_0_234 VGND VPWR sky130_fd_sc_hd__tapvpwrvgnd_1
XFILLER_25_135 VGND VGND VPWR VPWR sky130_fd_sc_hd__decap_3
XFILLER_26_669 VGND VGND VPWR VPWR sky130_fd_sc_hd__decap_3
XFILLER_41_606 VGND VGND VPWR VPWR sky130_fd_sc_hd__decap_3
XFILLER_53_455 VGND VGND VPWR VPWR sky130_fd_sc_hd__decap_3
XFILLER_80_230 VGND VGND VPWR VPWR sky130_fd_sc_hd__decap_3
X_6986_ _7398_/CLK _6986_/D _6266_/Y VGND VGND VPWR VPWR _6986_/Q sky130_fd_sc_hd__dfrtp_2
XTAP_TAPCELL_ROW_0_256 VGND VPWR sky130_fd_sc_hd__tapvpwrvgnd_1
XFILLER_41_617 VGND VGND VPWR VPWR sky130_fd_sc_hd__decap_3
XTAP_TAPCELL_ROW_36_686 VGND VPWR sky130_fd_sc_hd__tapvpwrvgnd_1
XFILLER_15_69 VGND VGND VPWR VPWR sky130_fd_sc_hd__decap_3
XFILLER_21_330 VGND VGND VPWR VPWR sky130_fd_sc_hd__decap_3
X_4819_ _7002_/Q _4834_/A _4818_/Y _4927_/A VGND VGND VPWR VPWR _4819_/X sky130_fd_sc_hd__o211a_2
XTAP_TAPCELL_ROW_97_1419 VGND VPWR sky130_fd_sc_hd__tapvpwrvgnd_1
XFILLER_5_529 VGND VGND VPWR VPWR sky130_fd_sc_hd__decap_3
XFILLER_107_435 VGND VGND VPWR VPWR sky130_fd_sc_hd__decap_3
XFILLER_110_6 VGND VGND VPWR VPWR sky130_fd_sc_hd__decap_3
XFILLER_107_479 VGND VGND VPWR VPWR sky130_fd_sc_hd__decap_3
XTAP_TAPCELL_ROW_8_345 VGND VPWR sky130_fd_sc_hd__tapvpwrvgnd_1
XFILLER_103_641 VGND VGND VPWR VPWR sky130_fd_sc_hd__decap_3
XFILLER_0_267 VGND VGND VPWR VPWR sky130_fd_sc_hd__decap_3
XFILLER_103_685 VGND VGND VPWR VPWR sky130_fd_sc_hd__decap_3
XFILLER_76_525 VGND VGND VPWR VPWR sky130_fd_sc_hd__fill_2
XFILLER_88_374 VGND VGND VPWR VPWR sky130_fd_sc_hd__decap_3
XFILLER_56_21 VGND VGND VPWR VPWR sky130_fd_sc_hd__decap_3
XFILLER_56_32 VGND VGND VPWR VPWR sky130_fd_sc_hd__decap_3
XFILLER_76_536 VGND VGND VPWR VPWR sky130_fd_sc_hd__decap_3
XFILLER_76_569 VGND VGND VPWR VPWR sky130_fd_sc_hd__decap_3
XFILLER_17_603 VGND VGND VPWR VPWR sky130_fd_sc_hd__decap_3
XFILLER_63_219 VGND VGND VPWR VPWR sky130_fd_sc_hd__decap_3
XFILLER_91_517 VGND VGND VPWR VPWR sky130_fd_sc_hd__decap_3
XFILLER_91_528 VGND VGND VPWR VPWR sky130_fd_sc_hd__decap_3
XFILLER_17_647 VGND VGND VPWR VPWR sky130_fd_sc_hd__decap_3
XFILLER_56_282 VGND VGND VPWR VPWR sky130_fd_sc_hd__decap_3
XFILLER_56_98 VGND VGND VPWR VPWR sky130_fd_sc_hd__fill_2
XTAP_TAPCELL_ROW_106_1526 VGND VPWR sky130_fd_sc_hd__tapvpwrvgnd_1
XPHY_EDGE_ROW_19_Right_19 VGND VGND VPWR VPWR sky130_fd_sc_hd__decap_3
XFILLER_112_71 VGND VGND VPWR VPWR sky130_fd_sc_hd__decap_3
XFILLER_32_628 VGND VGND VPWR VPWR sky130_fd_sc_hd__decap_3
XFILLER_71_296 VGND VGND VPWR VPWR sky130_fd_sc_hd__fill_2
XFILLER_12_352 VGND VGND VPWR VPWR sky130_fd_sc_hd__decap_3
XFILLER_40_672 VGND VGND VPWR VPWR sky130_fd_sc_hd__decap_3
XFILLER_72_97 VGND VGND VPWR VPWR sky130_fd_sc_hd__decap_3
XFILLER_8_312 VGND VGND VPWR VPWR sky130_fd_sc_hd__decap_3
XFILLER_12_374 VGND VGND VPWR VPWR sky130_fd_sc_hd__fill_2
XFILLER_12_396 VGND VGND VPWR VPWR sky130_fd_sc_hd__decap_3
XFILLER_8_334 VGND VGND VPWR VPWR sky130_fd_sc_hd__decap_3
Xclkbuf_3_1__f_clk clkbuf_0_clk/X VGND VGND VPWR VPWR clkload0/A sky130_fd_sc_hd__clkbuf_16
XFILLER_113_405 VGND VGND VPWR VPWR sky130_fd_sc_hd__decap_3
XFILLER_4_551 VGND VGND VPWR VPWR sky130_fd_sc_hd__decap_3
XPHY_EDGE_ROW_28_Right_28 VGND VGND VPWR VPWR sky130_fd_sc_hd__decap_3
XFILLER_99_617 VGND VGND VPWR VPWR sky130_fd_sc_hd__decap_3
XFILLER_99_606 VGND VGND VPWR VPWR sky130_fd_sc_hd__decap_3
XFILLER_113_438 VGND VGND VPWR VPWR sky130_fd_sc_hd__decap_3
XFILLER_4_584 VGND VGND VPWR VPWR sky130_fd_sc_hd__decap_3
XFILLER_4_595 VGND VGND VPWR VPWR sky130_fd_sc_hd__decap_3
XFILLER_98_127 VGND VGND VPWR VPWR sky130_fd_sc_hd__decap_3
XFILLER_113_449 VGND VGND VPWR VPWR sky130_fd_sc_hd__decap_3
XFILLER_39_216 VGND VGND VPWR VPWR sky130_fd_sc_hd__fill_2
XFILLER_67_558 VGND VGND VPWR VPWR sky130_fd_sc_hd__fill_2
XFILLER_47_260 VGND VGND VPWR VPWR sky130_fd_sc_hd__decap_3
XFILLER_75_591 VGND VGND VPWR VPWR sky130_fd_sc_hd__decap_3
XFILLER_82_528 VGND VGND VPWR VPWR sky130_fd_sc_hd__decap_3
XFILLER_82_539 VGND VGND VPWR VPWR sky130_fd_sc_hd__decap_3
XPHY_EDGE_ROW_37_Right_37 VGND VGND VPWR VPWR sky130_fd_sc_hd__decap_3
XFILLER_23_606 VGND VGND VPWR VPWR sky130_fd_sc_hd__decap_3
XFILLER_35_444 VGND VGND VPWR VPWR sky130_fd_sc_hd__decap_3
XFILLER_47_293 VGND VGND VPWR VPWR sky130_fd_sc_hd__decap_3
XFILLER_62_241 VGND VGND VPWR VPWR sky130_fd_sc_hd__decap_3
X_6840_ _6970_/CLK _6840_/D VGND VGND VPWR VPWR _6840_/Q sky130_fd_sc_hd__dfxtp_2
XFILLER_23_617 VGND VGND VPWR VPWR sky130_fd_sc_hd__decap_3
XFILLER_35_477 VGND VGND VPWR VPWR sky130_fd_sc_hd__decap_3
XFILLER_90_572 VGND VGND VPWR VPWR sky130_fd_sc_hd__decap_3
X_6771_ _6978_/CLK _6771_/D VGND VGND VPWR VPWR _6771_/Q sky130_fd_sc_hd__dfxtp_2
XFILLER_22_138 VGND VGND VPWR VPWR sky130_fd_sc_hd__fill_2
XFILLER_50_436 VGND VGND VPWR VPWR sky130_fd_sc_hd__decap_3
X_3983_ _7349_/Q _4524_/A0 _4471_/S VGND VGND VPWR VPWR _7349_/D sky130_fd_sc_hd__mux2_2
XTAP_TAPCELL_ROW_33_645 VGND VPWR sky130_fd_sc_hd__tapvpwrvgnd_1
XFILLER_31_650 VGND VGND VPWR VPWR sky130_fd_sc_hd__decap_3
XTAP_TAPCELL_ROW_61_987 VGND VPWR sky130_fd_sc_hd__tapvpwrvgnd_1
X_5653_ _5664_/B VGND VGND VPWR VPWR _5653_/Y sky130_fd_sc_hd__inv_2
X_4604_ _4667_/B VGND VGND VPWR VPWR _4671_/B sky130_fd_sc_hd__inv_2
XPHY_EDGE_ROW_46_Right_46 VGND VGND VPWR VPWR sky130_fd_sc_hd__decap_3
X_7323_ _7355_/CLK _7323_/D _6603_/Y VGND VGND VPWR VPWR _7323_/Q sky130_fd_sc_hd__dfrtp_2
XFILLER_89_116 VGND VGND VPWR VPWR sky130_fd_sc_hd__decap_3
X_7254_ _7349_/CLK _7254_/D _6534_/Y VGND VGND VPWR VPWR _7254_/Q sky130_fd_sc_hd__dfrtp_2
X_4466_ _5104_/A _5650_/A VGND VGND VPWR VPWR _4466_/Y sky130_fd_sc_hd__nand2_2
X_7185_ _7350_/CLK _7185_/D _6465_/Y VGND VGND VPWR VPWR _7185_/Q sky130_fd_sc_hd__dfrtp_2
X_4397_ _4397_/A _4648_/A VGND VGND VPWR VPWR _4397_/Y sky130_fd_sc_hd__nor2_2
X_3417_ _3449_/B _3421_/C _3417_/C VGND VGND VPWR VPWR _3417_/X sky130_fd_sc_hd__and3_2
XFILLER_112_460 VGND VGND VPWR VPWR sky130_fd_sc_hd__decap_3
X_3348_ _3371_/A _6980_/Q _6982_/Q VGND VGND VPWR VPWR _5130_/A sky130_fd_sc_hd__a21oi_2
XTAP_TAPCELL_ROW_5_315 VGND VPWR sky130_fd_sc_hd__tapvpwrvgnd_1
XFILLER_98_672 VGND VGND VPWR VPWR sky130_fd_sc_hd__decap_3
XFILLER_100_622 VGND VGND VPWR VPWR sky130_fd_sc_hd__decap_3
XFILLER_97_193 VGND VGND VPWR VPWR sky130_fd_sc_hd__decap_3
Xhold1001 _7260_/Q VGND VGND VPWR VPWR _5028_/A0 sky130_fd_sc_hd__dlygate4sd3_1
Xhold1012 _7241_/Q VGND VGND VPWR VPWR _5173_/A sky130_fd_sc_hd__dlygate4sd3_1
Xhold1023 _7206_/Q VGND VGND VPWR VPWR _5247_/A0 sky130_fd_sc_hd__dlygate4sd3_1
XFILLER_100_666 VGND VGND VPWR VPWR sky130_fd_sc_hd__decap_3
XFILLER_45_208 VGND VGND VPWR VPWR sky130_fd_sc_hd__decap_3
XFILLER_85_355 VGND VGND VPWR VPWR sky130_fd_sc_hd__fill_1
XFILLER_85_377 VGND VGND VPWR VPWR sky130_fd_sc_hd__fill_2
Xhold1034 _7386_/Q VGND VGND VPWR VPWR _3860_/A0 sky130_fd_sc_hd__dlygate4sd3_1
Xhold1045 _7212_/Q VGND VGND VPWR VPWR _5236_/A0 sky130_fd_sc_hd__dlygate4sd3_1
Xhold1056 _7217_/Q VGND VGND VPWR VPWR _5223_/A sky130_fd_sc_hd__dlygate4sd3_1
Xhold1067 _7221_/Q VGND VGND VPWR VPWR _5215_/A sky130_fd_sc_hd__dlygate4sd3_1
XPHY_EDGE_ROW_55_Right_55 VGND VGND VPWR VPWR sky130_fd_sc_hd__decap_3
XFILLER_26_411 VGND VGND VPWR VPWR sky130_fd_sc_hd__decap_3
XFILLER_38_282 VGND VGND VPWR VPWR sky130_fd_sc_hd__decap_3
XFILLER_85_388 VGND VGND VPWR VPWR sky130_fd_sc_hd__decap_3
Xhold1078 _7303_/Q VGND VGND VPWR VPWR _4554_/A sky130_fd_sc_hd__dlygate4sd3_1
Xhold1089 _7017_/Q VGND VGND VPWR VPWR _5621_/A sky130_fd_sc_hd__dlygate4sd3_1
X_5018_ _5018_/A _5018_/B VGND VGND VPWR VPWR _5018_/Y sky130_fd_sc_hd__nor2_2
XFILLER_14_628 VGND VGND VPWR VPWR sky130_fd_sc_hd__decap_3
XFILLER_26_466 VGND VGND VPWR VPWR sky130_fd_sc_hd__decap_3
XFILLER_26_477 VGND VGND VPWR VPWR sky130_fd_sc_hd__decap_3
XFILLER_53_252 VGND VGND VPWR VPWR sky130_fd_sc_hd__decap_3
XFILLER_81_561 VGND VGND VPWR VPWR sky130_fd_sc_hd__decap_3
XFILLER_41_458 VGND VGND VPWR VPWR sky130_fd_sc_hd__decap_3
XFILLER_53_296 VGND VGND VPWR VPWR sky130_fd_sc_hd__decap_3
XFILLER_81_594 VGND VGND VPWR VPWR sky130_fd_sc_hd__decap_3
X_6969_ _6974_/CLK _6969_/D VGND VGND VPWR VPWR _6969_/Q sky130_fd_sc_hd__dfxtp_2
XFILLER_9_109 VGND VGND VPWR VPWR sky130_fd_sc_hd__decap_3
XFILLER_22_672 VGND VGND VPWR VPWR sky130_fd_sc_hd__decap_3
XFILLER_42_56 VGND VGND VPWR VPWR sky130_fd_sc_hd__decap_3
XTAP_TAPCELL_ROW_101_1467 VGND VPWR sky130_fd_sc_hd__tapvpwrvgnd_1
XPHY_EDGE_ROW_64_Right_64 VGND VGND VPWR VPWR sky130_fd_sc_hd__decap_3
XFILLER_5_304 VGND VGND VPWR VPWR sky130_fd_sc_hd__decap_3
XFILLER_107_210 VGND VGND VPWR VPWR sky130_fd_sc_hd__decap_3
XFILLER_5_326 VGND VGND VPWR VPWR sky130_fd_sc_hd__decap_3
XFILLER_107_287 VGND VGND VPWR VPWR sky130_fd_sc_hd__decap_3
XFILLER_1_532 VGND VGND VPWR VPWR sky130_fd_sc_hd__decap_3
XFILLER_89_650 VGND VGND VPWR VPWR sky130_fd_sc_hd__decap_3
Xhold890 _7070_/Q VGND VGND VPWR VPWR _7070_/D sky130_fd_sc_hd__dlygate4sd3_1
XFILLER_107_60 VGND VGND VPWR VPWR sky130_fd_sc_hd__fill_1
XFILLER_49_503 VGND VGND VPWR VPWR sky130_fd_sc_hd__fill_1
XFILLER_67_20 VGND VGND VPWR VPWR sky130_fd_sc_hd__decap_3
XFILLER_103_471 VGND VGND VPWR VPWR sky130_fd_sc_hd__decap_3
XFILLER_1_598 VGND VGND VPWR VPWR sky130_fd_sc_hd__decap_3
XFILLER_49_558 VGND VGND VPWR VPWR sky130_fd_sc_hd__fill_2
XTAP_TAPCELL_ROW_112_1596 VGND VPWR sky130_fd_sc_hd__tapvpwrvgnd_1
XPHY_EDGE_ROW_73_Right_73 VGND VGND VPWR VPWR sky130_fd_sc_hd__decap_3
XFILLER_17_411 VGND VGND VPWR VPWR sky130_fd_sc_hd__decap_3
XFILLER_57_591 VGND VGND VPWR VPWR sky130_fd_sc_hd__decap_3
XFILLER_64_539 VGND VGND VPWR VPWR sky130_fd_sc_hd__decap_3
XFILLER_29_293 VGND VGND VPWR VPWR sky130_fd_sc_hd__decap_3
XFILLER_72_583 VGND VGND VPWR VPWR sky130_fd_sc_hd__decap_3
XFILLER_83_85 VGND VGND VPWR VPWR sky130_fd_sc_hd__decap_3
XTAP_TAPCELL_ROW_67_1053 VGND VPWR sky130_fd_sc_hd__tapvpwrvgnd_1
XFILLER_32_436 VGND VGND VPWR VPWR sky130_fd_sc_hd__decap_3
XPHY_EDGE_ROW_17_Left_134 VGND VGND VPWR VPWR sky130_fd_sc_hd__decap_3
XFILLER_13_650 VGND VGND VPWR VPWR sky130_fd_sc_hd__decap_3
XPHY_EDGE_ROW_82_Right_82 VGND VGND VPWR VPWR sky130_fd_sc_hd__decap_3
XFILLER_40_480 VGND VGND VPWR VPWR sky130_fd_sc_hd__decap_3
XTAP_TAPCELL_ROW_30_615 VGND VPWR sky130_fd_sc_hd__tapvpwrvgnd_1
XFILLER_9_632 VGND VGND VPWR VPWR sky130_fd_sc_hd__decap_3
XFILLER_8_153 VGND VGND VPWR VPWR sky130_fd_sc_hd__decap_3
XFILLER_9_676 VGND VGND VPWR VPWR sky130_fd_sc_hd__decap_3
XFILLER_9_665 VGND VGND VPWR VPWR sky130_fd_sc_hd__decap_3
XFILLER_8_197 VGND VGND VPWR VPWR sky130_fd_sc_hd__decap_3
XTAP_TAPCELL_ROW_10_372 VGND VPWR sky130_fd_sc_hd__tapvpwrvgnd_1
XFILLER_113_202 VGND VGND VPWR VPWR sky130_fd_sc_hd__decap_3
X_4320_ _7066_/Q _4305_/B _4460_/A VGND VGND VPWR VPWR _4362_/B sky130_fd_sc_hd__o21a_2
XTAP_TAPCELL_ROW_78_1193 VGND VPWR sky130_fd_sc_hd__tapvpwrvgnd_1
XTAP_TAPCELL_ROW_78_1182 VGND VPWR sky130_fd_sc_hd__tapvpwrvgnd_1
XFILLER_87_609 VGND VGND VPWR VPWR sky130_fd_sc_hd__decap_3
X_4251_ _7016_/Q _4356_/A2 _4351_/B1 _7133_/Q _4250_/X VGND VGND VPWR VPWR _4251_/X
+ sky130_fd_sc_hd__a221o_2
XPHY_EDGE_ROW_26_Left_143 VGND VGND VPWR VPWR sky130_fd_sc_hd__decap_3
XFILLER_113_257 VGND VGND VPWR VPWR sky130_fd_sc_hd__decap_3
XFILLER_113_279 VGND VGND VPWR VPWR sky130_fd_sc_hd__fill_1
XFILLER_79_160 VGND VGND VPWR VPWR sky130_fd_sc_hd__decap_3
XPHY_EDGE_ROW_91_Right_91 VGND VGND VPWR VPWR sky130_fd_sc_hd__decap_3
XFILLER_67_322 VGND VGND VPWR VPWR sky130_fd_sc_hd__decap_3
XFILLER_67_333 VGND VGND VPWR VPWR sky130_fd_sc_hd__decap_3
XFILLER_95_620 VGND VGND VPWR VPWR sky130_fd_sc_hd__decap_3
X_4182_ _7136_/Q _4267_/A2 _4180_/X _4181_/X VGND VGND VPWR VPWR _4182_/X sky130_fd_sc_hd__a211o_2
XFILLER_55_517 VGND VGND VPWR VPWR sky130_fd_sc_hd__decap_3
XFILLER_95_653 VGND VGND VPWR VPWR sky130_fd_sc_hd__decap_3
XTAP_TAPCELL_ROW_38_704 VGND VPWR sky130_fd_sc_hd__tapvpwrvgnd_1
XFILLER_103_18 VGND VGND VPWR VPWR sky130_fd_sc_hd__decap_3
XFILLER_82_303 VGND VGND VPWR VPWR sky130_fd_sc_hd__decap_3
XFILLER_82_336 VGND VGND VPWR VPWR sky130_fd_sc_hd__decap_3
XFILLER_94_174 VGND VGND VPWR VPWR sky130_fd_sc_hd__decap_3
XFILLER_35_274 VGND VGND VPWR VPWR sky130_fd_sc_hd__fill_1
XFILLER_50_200 VGND VGND VPWR VPWR sky130_fd_sc_hd__decap_3
XFILLER_63_561 VGND VGND VPWR VPWR sky130_fd_sc_hd__decap_3
XPHY_EDGE_ROW_35_Left_152 VGND VGND VPWR VPWR sky130_fd_sc_hd__decap_3
XFILLER_23_425 VGND VGND VPWR VPWR sky130_fd_sc_hd__decap_3
XFILLER_23_447 VGND VGND VPWR VPWR sky130_fd_sc_hd__fill_1
XFILLER_63_594 VGND VGND VPWR VPWR sky130_fd_sc_hd__decap_3
XFILLER_90_380 VGND VGND VPWR VPWR sky130_fd_sc_hd__fill_1
X_6823_ _6974_/CLK _6823_/D VGND VGND VPWR VPWR _6823_/Q sky130_fd_sc_hd__dfxtp_2
XTAP_TAPCELL_ROW_18_472 VGND VPWR sky130_fd_sc_hd__tapvpwrvgnd_1
XFILLER_11_609 VGND VGND VPWR VPWR sky130_fd_sc_hd__decap_3
X_6754_ _6968_/CLK _6754_/D VGND VGND VPWR VPWR _6754_/Q sky130_fd_sc_hd__dfxtp_2
X_3966_ _7357_/Q hold980/X _3968_/S VGND VGND VPWR VPWR _7357_/D sky130_fd_sc_hd__mux2_2
X_6685_ _6685_/A VGND VGND VPWR VPWR _6685_/Y sky130_fd_sc_hd__inv_2
X_5705_ hold906/X _5737_/S _4270_/Y VGND VGND VPWR VPWR _6702_/D sky130_fd_sc_hd__a21bo_2
XFILLER_109_508 VGND VGND VPWR VPWR sky130_fd_sc_hd__decap_3
X_3897_ hold990/X _5104_/A _3896_/Y VGND VGND VPWR VPWR _7382_/D sky130_fd_sc_hd__a21bo_2
X_5567_ hold978/X _4960_/A _4870_/Y VGND VGND VPWR VPWR _7050_/D sky130_fd_sc_hd__a21o_2
X_7306_ _7365_/CLK _7306_/D _6586_/Y VGND VGND VPWR VPWR _7306_/Q sky130_fd_sc_hd__dfrtp_2
XPHY_EDGE_ROW_44_Left_161 VGND VGND VPWR VPWR sky130_fd_sc_hd__decap_3
XFILLER_5_9 VGND VGND VPWR VPWR sky130_fd_sc_hd__decap_3
X_7237_ _7365_/CLK _7237_/D _6517_/Y VGND VGND VPWR VPWR _7237_/Q sky130_fd_sc_hd__dfrtp_2
X_4449_ _4403_/A _4411_/B _4448_/X VGND VGND VPWR VPWR _4761_/C sky130_fd_sc_hd__a21oi_2
XFILLER_58_322 VGND VGND VPWR VPWR sky130_fd_sc_hd__decap_3
XFILLER_86_631 VGND VGND VPWR VPWR sky130_fd_sc_hd__decap_3
X_7168_ _7364_/CLK _7168_/D _6448_/Y VGND VGND VPWR VPWR _7168_/Q sky130_fd_sc_hd__dfrtp_2
XFILLER_98_480 VGND VGND VPWR VPWR sky130_fd_sc_hd__decap_3
XFILLER_86_675 VGND VGND VPWR VPWR sky130_fd_sc_hd__decap_3
X_7099_ _7322_/CLK _7099_/D _6379_/Y VGND VGND VPWR VPWR _7099_/Q sky130_fd_sc_hd__dfrtp_2
XFILLER_85_163 VGND VGND VPWR VPWR sky130_fd_sc_hd__decap_3
XFILLER_85_185 VGND VGND VPWR VPWR sky130_fd_sc_hd__decap_3
XFILLER_39_591 VGND VGND VPWR VPWR sky130_fd_sc_hd__decap_3
XFILLER_73_358 VGND VGND VPWR VPWR sky130_fd_sc_hd__decap_3
XPHY_EDGE_ROW_53_Left_170 VGND VGND VPWR VPWR sky130_fd_sc_hd__decap_3
XFILLER_54_572 VGND VGND VPWR VPWR sky130_fd_sc_hd__decap_3
XFILLER_14_436 VGND VGND VPWR VPWR sky130_fd_sc_hd__decap_3
XFILLER_81_380 VGND VGND VPWR VPWR sky130_fd_sc_hd__decap_3
XFILLER_41_255 VGND VGND VPWR VPWR sky130_fd_sc_hd__decap_3
XFILLER_53_66 VGND VGND VPWR VPWR sky130_fd_sc_hd__fill_1
XFILLER_22_480 VGND VGND VPWR VPWR sky130_fd_sc_hd__decap_3
XFILLER_41_299 VGND VGND VPWR VPWR sky130_fd_sc_hd__fill_2
XFILLER_10_631 VGND VGND VPWR VPWR sky130_fd_sc_hd__decap_3
XFILLER_10_675 VGND VGND VPWR VPWR sky130_fd_sc_hd__decap_3
XFILLER_6_613 VGND VGND VPWR VPWR sky130_fd_sc_hd__decap_3
XFILLER_5_145 VGND VGND VPWR VPWR sky130_fd_sc_hd__fill_2
XFILLER_6_657 VGND VGND VPWR VPWR sky130_fd_sc_hd__decap_3
XFILLER_108_563 VGND VGND VPWR VPWR sky130_fd_sc_hd__decap_3
XFILLER_5_167 VGND VGND VPWR VPWR sky130_fd_sc_hd__fill_1
XTAP_TAPCELL_ROW_114_1625 VGND VPWR sky130_fd_sc_hd__tapvpwrvgnd_1
XTAP_TAPCELL_ROW_114_1614 VGND VPWR sky130_fd_sc_hd__tapvpwrvgnd_1
XFILLER_69_609 VGND VGND VPWR VPWR sky130_fd_sc_hd__decap_3
XFILLER_78_63 VGND VGND VPWR VPWR sky130_fd_sc_hd__decap_3
XFILLER_78_85 VGND VGND VPWR VPWR sky130_fd_sc_hd__decap_3
XFILLER_77_620 VGND VGND VPWR VPWR sky130_fd_sc_hd__decap_3
XFILLER_103_290 VGND VGND VPWR VPWR sky130_fd_sc_hd__decap_3
XFILLER_110_249 VGND VGND VPWR VPWR sky130_fd_sc_hd__decap_3
XFILLER_49_355 VGND VGND VPWR VPWR sky130_fd_sc_hd__decap_3
XFILLER_76_152 VGND VGND VPWR VPWR sky130_fd_sc_hd__decap_3
XFILLER_77_653 VGND VGND VPWR VPWR sky130_fd_sc_hd__decap_3
XFILLER_92_601 VGND VGND VPWR VPWR sky130_fd_sc_hd__decap_3
XFILLER_49_388 VGND VGND VPWR VPWR sky130_fd_sc_hd__decap_3
XFILLER_92_634 VGND VGND VPWR VPWR sky130_fd_sc_hd__decap_3
XFILLER_91_122 VGND VGND VPWR VPWR sky130_fd_sc_hd__decap_3
XFILLER_92_645 VGND VGND VPWR VPWR sky130_fd_sc_hd__decap_3
XFILLER_94_73 VGND VGND VPWR VPWR sky130_fd_sc_hd__decap_3
XFILLER_45_561 VGND VGND VPWR VPWR sky130_fd_sc_hd__decap_3
XFILLER_92_678 VGND VGND VPWR VPWR sky130_fd_sc_hd__decap_3
XFILLER_32_200 VGND VGND VPWR VPWR sky130_fd_sc_hd__decap_3
XFILLER_45_594 VGND VGND VPWR VPWR sky130_fd_sc_hd__decap_3
XFILLER_60_564 VGND VGND VPWR VPWR sky130_fd_sc_hd__decap_3
X_3820_ _6927_/Q _3918_/A2 _3903_/B1 _6701_/Q VGND VGND VPWR VPWR _3820_/X sky130_fd_sc_hd__a22o_2
XTAP_TAPCELL_ROW_43_762 VGND VPWR sky130_fd_sc_hd__tapvpwrvgnd_1
XTAP_TAPCELL_ROW_15_431 VGND VPWR sky130_fd_sc_hd__tapvpwrvgnd_1
XFILLER_20_428 VGND VGND VPWR VPWR sky130_fd_sc_hd__decap_3
X_3751_ _6935_/Q _3768_/A2 _3925_/B1 _6887_/Q VGND VGND VPWR VPWR _3751_/X sky130_fd_sc_hd__a22o_2
XTAP_TAPCELL_ROW_43_773 VGND VPWR sky130_fd_sc_hd__tapvpwrvgnd_1
X_6470_ _6632_/A VGND VGND VPWR VPWR _6470_/Y sky130_fd_sc_hd__inv_2
X_3682_ _3682_/A _3682_/B VGND VGND VPWR VPWR _3682_/Y sky130_fd_sc_hd__nand2_2
X_5421_ _5421_/A0 _5135_/X _5429_/S VGND VGND VPWR VPWR _7123_/D sky130_fd_sc_hd__mux2_2
X_5352_ _5352_/A0 _5135_/X _7412_/A VGND VGND VPWR VPWR _7155_/D sky130_fd_sc_hd__mux2_2
XFILLER_114_522 VGND VGND VPWR VPWR sky130_fd_sc_hd__decap_3
XFILLER_114_533 VGND VGND VPWR VPWR sky130_fd_sc_hd__decap_3
X_4303_ _7320_/Q _3989_/S _4348_/B1 _7128_/Q _4302_/X VGND VGND VPWR VPWR _4303_/X
+ sky130_fd_sc_hd__a221o_2
XFILLER_99_222 VGND VGND VPWR VPWR sky130_fd_sc_hd__fill_2
XFILLER_101_205 VGND VGND VPWR VPWR sky130_fd_sc_hd__decap_3
XFILLER_114_566 VGND VGND VPWR VPWR sky130_fd_sc_hd__decap_3
XFILLER_87_417 VGND VGND VPWR VPWR sky130_fd_sc_hd__decap_3
X_7022_ _7372_/CLK _7022_/D _6302_/Y VGND VGND VPWR VPWR _7022_/Q sky130_fd_sc_hd__dfrtp_2
X_5283_ _3600_/A _4788_/A _5238_/X _5283_/B2 VGND VGND VPWR VPWR _7188_/D sky130_fd_sc_hd__a22o_2
XFILLER_68_631 VGND VGND VPWR VPWR sky130_fd_sc_hd__decap_3
X_4234_ _7355_/Q _4338_/B1 _4233_/X _4248_/A VGND VGND VPWR VPWR _4234_/X sky130_fd_sc_hd__a211o_2
XFILLER_99_288 VGND VGND VPWR VPWR sky130_fd_sc_hd__decap_3
XFILLER_28_506 VGND VGND VPWR VPWR sky130_fd_sc_hd__decap_3
XFILLER_68_675 VGND VGND VPWR VPWR sky130_fd_sc_hd__decap_3
X_4165_ _7018_/Q _4422_/A2 _4434_/B1 _7137_/Q _4164_/X VGND VGND VPWR VPWR _4165_/X
+ sky130_fd_sc_hd__a221o_2
XFILLER_28_539 VGND VGND VPWR VPWR sky130_fd_sc_hd__decap_3
XFILLER_67_163 VGND VGND VPWR VPWR sky130_fd_sc_hd__decap_3
XFILLER_82_111 VGND VGND VPWR VPWR sky130_fd_sc_hd__decap_3
XFILLER_83_612 VGND VGND VPWR VPWR sky130_fd_sc_hd__decap_3
XFILLER_83_623 VGND VGND VPWR VPWR sky130_fd_sc_hd__decap_3
XFILLER_55_347 VGND VGND VPWR VPWR sky130_fd_sc_hd__fill_2
XFILLER_67_196 VGND VGND VPWR VPWR sky130_fd_sc_hd__decap_3
XFILLER_82_122 VGND VGND VPWR VPWR sky130_fd_sc_hd__decap_3
XFILLER_82_144 VGND VGND VPWR VPWR sky130_fd_sc_hd__decap_3
XFILLER_83_656 VGND VGND VPWR VPWR sky130_fd_sc_hd__decap_3
X_4096_ _4096_/A _4096_/B VGND VGND VPWR VPWR _4633_/A sky130_fd_sc_hd__nand2_2
XFILLER_36_572 VGND VGND VPWR VPWR sky130_fd_sc_hd__decap_3
XFILLER_23_200 VGND VGND VPWR VPWR sky130_fd_sc_hd__decap_3
XFILLER_63_380 VGND VGND VPWR VPWR sky130_fd_sc_hd__decap_3
XFILLER_82_188 VGND VGND VPWR VPWR sky130_fd_sc_hd__decap_3
XFILLER_51_564 VGND VGND VPWR VPWR sky130_fd_sc_hd__decap_3
Xplace380 _4791_/A1 VGND VGND VPWR VPWR _3822_/A2 sky130_fd_sc_hd__buf_2
Xplace391 _5666_/A VGND VGND VPWR VPWR _4997_/A1 sky130_fd_sc_hd__buf_2
X_6806_ _6943_/CLK _6806_/D VGND VGND VPWR VPWR _6806_/Q sky130_fd_sc_hd__dfxtp_2
XFILLER_23_299 VGND VGND VPWR VPWR sky130_fd_sc_hd__decap_3
XFILLER_51_597 VGND VGND VPWR VPWR sky130_fd_sc_hd__decap_3
X_4998_ _4998_/A0 _4997_/X _5080_/S VGND VGND VPWR VPWR _7262_/D sky130_fd_sc_hd__mux2_2
X_6737_ _6959_/CLK _6737_/D VGND VGND VPWR VPWR _6737_/Q sky130_fd_sc_hd__dfxtp_2
X_3949_ _7365_/Q _4493_/A0 _3954_/S VGND VGND VPWR VPWR _7365_/D sky130_fd_sc_hd__mux2_2
X_6668_ _6672_/A VGND VGND VPWR VPWR _6668_/Y sky130_fd_sc_hd__inv_2
X_6599_ _6603_/A VGND VGND VPWR VPWR _6599_/Y sky130_fd_sc_hd__inv_2
X_5619_ _5619_/A _5622_/B VGND VGND VPWR VPWR _7018_/D sky130_fd_sc_hd__or2_2
XFILLER_105_511 VGND VGND VPWR VPWR sky130_fd_sc_hd__decap_3
XFILLER_105_544 VGND VGND VPWR VPWR sky130_fd_sc_hd__decap_3
XFILLER_3_6 VGND VGND VPWR VPWR sky130_fd_sc_hd__decap_3
XFILLER_3_638 VGND VGND VPWR VPWR sky130_fd_sc_hd__decap_3
XFILLER_105_588 VGND VGND VPWR VPWR sky130_fd_sc_hd__decap_3
XFILLER_59_620 VGND VGND VPWR VPWR sky130_fd_sc_hd__decap_3
XFILLER_58_130 VGND VGND VPWR VPWR sky130_fd_sc_hd__fill_2
XFILLER_58_141 VGND VGND VPWR VPWR sky130_fd_sc_hd__fill_2
XFILLER_59_653 VGND VGND VPWR VPWR sky130_fd_sc_hd__decap_3
XFILLER_19_528 VGND VGND VPWR VPWR sky130_fd_sc_hd__decap_3
XFILLER_73_100 VGND VGND VPWR VPWR sky130_fd_sc_hd__decap_3
XFILLER_74_601 VGND VGND VPWR VPWR sky130_fd_sc_hd__decap_3
XFILLER_74_634 VGND VGND VPWR VPWR sky130_fd_sc_hd__decap_3
XFILLER_86_472 VGND VGND VPWR VPWR sky130_fd_sc_hd__decap_3
XFILLER_0_29 VGND VGND VPWR VPWR sky130_fd_sc_hd__fill_2
XFILLER_100_293 VGND VGND VPWR VPWR sky130_fd_sc_hd__decap_3
XFILLER_74_645 VGND VGND VPWR VPWR sky130_fd_sc_hd__decap_3
XFILLER_27_550 VGND VGND VPWR VPWR sky130_fd_sc_hd__decap_3
XFILLER_27_561 VGND VGND VPWR VPWR sky130_fd_sc_hd__decap_3
XFILLER_64_32 VGND VGND VPWR VPWR sky130_fd_sc_hd__decap_3
XFILLER_74_678 VGND VGND VPWR VPWR sky130_fd_sc_hd__decap_3
XFILLER_14_200 VGND VGND VPWR VPWR sky130_fd_sc_hd__decap_3
XFILLER_27_594 VGND VGND VPWR VPWR sky130_fd_sc_hd__decap_3
XFILLER_42_520 VGND VGND VPWR VPWR sky130_fd_sc_hd__decap_3
XTAP_TAPCELL_ROW_64_1023 VGND VPWR sky130_fd_sc_hd__tapvpwrvgnd_1
XFILLER_9_27 VGND VGND VPWR VPWR sky130_fd_sc_hd__decap_3
XFILLER_14_288 VGND VGND VPWR VPWR sky130_fd_sc_hd__fill_1
XFILLER_42_575 VGND VGND VPWR VPWR sky130_fd_sc_hd__decap_3
XTAP_TAPCELL_ROW_12_401 VGND VPWR sky130_fd_sc_hd__tapvpwrvgnd_1
XFILLER_80_64 VGND VGND VPWR VPWR sky130_fd_sc_hd__decap_3
Xfanout70 _6494_/A VGND VGND VPWR VPWR _6620_/A sky130_fd_sc_hd__buf_2
XTAP_TAPCELL_ROW_40_732 VGND VPWR sky130_fd_sc_hd__tapvpwrvgnd_1
XFILLER_10_461 VGND VGND VPWR VPWR sky130_fd_sc_hd__fill_2
XFILLER_10_472 VGND VGND VPWR VPWR sky130_fd_sc_hd__decap_3
XFILLER_6_432 VGND VGND VPWR VPWR sky130_fd_sc_hd__decap_3
XPHY_EDGE_ROW_108_Right_108 VGND VGND VPWR VPWR sky130_fd_sc_hd__decap_3
XTAP_TAPCELL_ROW_75_1152 VGND VPWR sky130_fd_sc_hd__tapvpwrvgnd_1
XFILLER_111_503 VGND VGND VPWR VPWR sky130_fd_sc_hd__fill_1
XFILLER_2_660 VGND VGND VPWR VPWR sky130_fd_sc_hd__decap_3
XFILLER_111_514 VGND VGND VPWR VPWR sky130_fd_sc_hd__decap_3
XFILLER_111_547 VGND VGND VPWR VPWR sky130_fd_sc_hd__decap_3
XFILLER_96_214 VGND VGND VPWR VPWR sky130_fd_sc_hd__fill_1
XFILLER_64_100 VGND VGND VPWR VPWR sky130_fd_sc_hd__decap_3
XFILLER_65_612 VGND VGND VPWR VPWR sky130_fd_sc_hd__decap_3
XFILLER_65_623 VGND VGND VPWR VPWR sky130_fd_sc_hd__decap_3
XFILLER_77_483 VGND VGND VPWR VPWR sky130_fd_sc_hd__decap_3
XFILLER_49_196 VGND VGND VPWR VPWR sky130_fd_sc_hd__fill_2
XFILLER_65_656 VGND VGND VPWR VPWR sky130_fd_sc_hd__decap_3
XTAP_TAPCELL_ROW_48_832 VGND VPWR sky130_fd_sc_hd__tapvpwrvgnd_1
XFILLER_64_155 VGND VGND VPWR VPWR sky130_fd_sc_hd__decap_3
XFILLER_80_604 VGND VGND VPWR VPWR sky130_fd_sc_hd__decap_3
XFILLER_92_464 VGND VGND VPWR VPWR sky130_fd_sc_hd__decap_3
XFILLER_18_572 VGND VGND VPWR VPWR sky130_fd_sc_hd__decap_3
XFILLER_80_637 VGND VGND VPWR VPWR sky130_fd_sc_hd__decap_3
XFILLER_80_648 VGND VGND VPWR VPWR sky130_fd_sc_hd__decap_3
X_4921_ _4968_/A _4383_/C _4201_/X VGND VGND VPWR VPWR _4937_/B sky130_fd_sc_hd__a21bo_2
XTAP_TAPCELL_ROW_86_1281 VGND VPWR sky130_fd_sc_hd__tapvpwrvgnd_1
XFILLER_33_564 VGND VGND VPWR VPWR sky130_fd_sc_hd__decap_3
XFILLER_45_391 VGND VGND VPWR VPWR sky130_fd_sc_hd__fill_1
X_4852_ _4852_/A _5057_/A VGND VGND VPWR VPWR _5101_/A sky130_fd_sc_hd__and2_2
XFILLER_20_203 VGND VGND VPWR VPWR sky130_fd_sc_hd__fill_2
XFILLER_20_214 VGND VGND VPWR VPWR sky130_fd_sc_hd__decap_3
XFILLER_33_597 VGND VGND VPWR VPWR sky130_fd_sc_hd__decap_3
X_3803_ _6816_/Q _3879_/B1 _3888_/B1 _6821_/Q VGND VGND VPWR VPWR _3803_/X sky130_fd_sc_hd__a22o_2
X_4783_ _4646_/A _4646_/B _4827_/A VGND VGND VPWR VPWR _4829_/B sky130_fd_sc_hd__a21boi_2
X_6522_ _6680_/A VGND VGND VPWR VPWR _6522_/Y sky130_fd_sc_hd__inv_2
X_3734_ _3728_/Y _3730_/X _3732_/X _3733_/X VGND VGND VPWR VPWR _3734_/X sky130_fd_sc_hd__a22o_2
XFILLER_109_17 VGND VGND VPWR VPWR sky130_fd_sc_hd__decap_3
X_6453_ _6614_/A VGND VGND VPWR VPWR _6453_/Y sky130_fd_sc_hd__inv_2
X_3665_ _3665_/A _3665_/B VGND VGND VPWR VPWR _3665_/X sky130_fd_sc_hd__and2_4
XFILLER_9_281 VGND VGND VPWR VPWR sky130_fd_sc_hd__fill_1
X_5404_ _5404_/A0 _5040_/X _5425_/S VGND VGND VPWR VPWR _7131_/D sky130_fd_sc_hd__mux2_2
X_6384_ _6608_/A VGND VGND VPWR VPWR _6384_/Y sky130_fd_sc_hd__inv_2
X_3596_ _4295_/B _3607_/B VGND VGND VPWR VPWR _3598_/A sky130_fd_sc_hd__and2_2
XFILLER_102_525 VGND VGND VPWR VPWR sky130_fd_sc_hd__decap_3
XFILLER_102_536 VGND VGND VPWR VPWR sky130_fd_sc_hd__decap_3
X_5266_ _5266_/A0 _5011_/X _5286_/S VGND VGND VPWR VPWR _7197_/D sky130_fd_sc_hd__mux2_2
XFILLER_102_569 VGND VGND VPWR VPWR sky130_fd_sc_hd__decap_3
XFILLER_87_269 VGND VGND VPWR VPWR sky130_fd_sc_hd__decap_3
X_7005_ _7374_/CLK _7005_/D _6285_/Y VGND VGND VPWR VPWR _7005_/Q sky130_fd_sc_hd__dfrtp_2
X_4217_ _3469_/A _3469_/B _3449_/A _7015_/Q _3365_/A VGND VGND VPWR VPWR _4217_/X
+ sky130_fd_sc_hd__o2111a_2
XFILLER_28_303 VGND VGND VPWR VPWR sky130_fd_sc_hd__decap_3
XFILLER_56_601 VGND VGND VPWR VPWR sky130_fd_sc_hd__decap_3
XFILLER_18_47 VGND VGND VPWR VPWR sky130_fd_sc_hd__decap_3
XFILLER_56_634 VGND VGND VPWR VPWR sky130_fd_sc_hd__decap_3
XFILLER_56_645 VGND VGND VPWR VPWR sky130_fd_sc_hd__decap_3
XFILLER_83_431 VGND VGND VPWR VPWR sky130_fd_sc_hd__decap_3
X_4148_ _7074_/Q _4265_/B _4145_/X _4147_/X VGND VGND VPWR VPWR _4205_/B sky130_fd_sc_hd__o22a_2
XFILLER_43_317 VGND VGND VPWR VPWR sky130_fd_sc_hd__decap_3
XFILLER_56_678 VGND VGND VPWR VPWR sky130_fd_sc_hd__decap_3
XFILLER_71_615 VGND VGND VPWR VPWR sky130_fd_sc_hd__fill_1
XFILLER_71_626 VGND VGND VPWR VPWR sky130_fd_sc_hd__decap_3
X_4079_ _7403_/Q _4437_/B1 _4077_/X _4078_/X VGND VGND VPWR VPWR _4079_/X sky130_fd_sc_hd__a211o_2
XFILLER_36_380 VGND VGND VPWR VPWR sky130_fd_sc_hd__decap_3
XFILLER_71_659 VGND VGND VPWR VPWR sky130_fd_sc_hd__decap_3
XFILLER_24_542 VGND VGND VPWR VPWR sky130_fd_sc_hd__decap_3
XTAP_TAPCELL_ROW_26_559 VGND VPWR sky130_fd_sc_hd__tapvpwrvgnd_1
XFILLER_24_575 VGND VGND VPWR VPWR sky130_fd_sc_hd__decap_3
XFILLER_11_225 VGND VGND VPWR VPWR sky130_fd_sc_hd__decap_3
XFILLER_50_23 VGND VGND VPWR VPWR sky130_fd_sc_hd__decap_3
Xclkload1 clkload1/A VGND VGND VPWR VPWR clkload1/X sky130_fd_sc_hd__clkbuf_16
XFILLER_3_424 VGND VGND VPWR VPWR sky130_fd_sc_hd__fill_2
XFILLER_1_3 VGND VGND VPWR VPWR sky130_fd_sc_hd__decap_3
XFILLER_3_446 VGND VGND VPWR VPWR sky130_fd_sc_hd__fill_2
XFILLER_78_203 VGND VGND VPWR VPWR sky130_fd_sc_hd__decap_3
XFILLER_115_60 VGND VGND VPWR VPWR sky130_fd_sc_hd__decap_3
XFILLER_19_314 VGND VGND VPWR VPWR sky130_fd_sc_hd__fill_1
XFILLER_47_612 VGND VGND VPWR VPWR sky130_fd_sc_hd__decap_3
XFILLER_47_623 VGND VGND VPWR VPWR sky130_fd_sc_hd__decap_3
XFILLER_59_472 VGND VGND VPWR VPWR sky130_fd_sc_hd__decap_3
XFILLER_93_228 VGND VGND VPWR VPWR sky130_fd_sc_hd__fill_1
XFILLER_101_591 VGND VGND VPWR VPWR sky130_fd_sc_hd__decap_3
XFILLER_115_93 VGND VGND VPWR VPWR sky130_fd_sc_hd__decap_3
XFILLER_47_656 VGND VGND VPWR VPWR sky130_fd_sc_hd__decap_3
XFILLER_86_280 VGND VGND VPWR VPWR sky130_fd_sc_hd__decap_3
XFILLER_86_291 VGND VGND VPWR VPWR sky130_fd_sc_hd__decap_3
XTAP_TAPCELL_ROW_70_1093 VGND VPWR sky130_fd_sc_hd__tapvpwrvgnd_1
XFILLER_34_306 VGND VGND VPWR VPWR sky130_fd_sc_hd__fill_2
XFILLER_46_144 VGND VGND VPWR VPWR sky130_fd_sc_hd__decap_3
XFILLER_62_604 VGND VGND VPWR VPWR sky130_fd_sc_hd__decap_3
XFILLER_74_475 VGND VGND VPWR VPWR sky130_fd_sc_hd__fill_1
XTAP_TAPCELL_ROW_109_1557 VGND VPWR sky130_fd_sc_hd__tapvpwrvgnd_1
XFILLER_15_520 VGND VGND VPWR VPWR sky130_fd_sc_hd__decap_3
XFILLER_34_339 VGND VGND VPWR VPWR sky130_fd_sc_hd__decap_3
XFILLER_46_188 VGND VGND VPWR VPWR sky130_fd_sc_hd__fill_2
XFILLER_62_637 VGND VGND VPWR VPWR sky130_fd_sc_hd__decap_3
XFILLER_62_648 VGND VGND VPWR VPWR sky130_fd_sc_hd__decap_3
XFILLER_15_553 VGND VGND VPWR VPWR sky130_fd_sc_hd__decap_3
XFILLER_61_169 VGND VGND VPWR VPWR sky130_fd_sc_hd__fill_1
XFILLER_15_564 VGND VGND VPWR VPWR sky130_fd_sc_hd__decap_3
XFILLER_15_597 VGND VGND VPWR VPWR sky130_fd_sc_hd__decap_3
XFILLER_70_681 VGND VGND VPWR VPWR sky130_fd_sc_hd__decap_3
XTAP_TAPCELL_ROW_53_890 VGND VPWR sky130_fd_sc_hd__tapvpwrvgnd_1
XFILLER_30_567 VGND VGND VPWR VPWR sky130_fd_sc_hd__decap_3
XFILLER_30_589 VGND VGND VPWR VPWR sky130_fd_sc_hd__decap_3
XFILLER_10_280 VGND VGND VPWR VPWR sky130_fd_sc_hd__decap_3
XFILLER_115_105 VGND VGND VPWR VPWR sky130_fd_sc_hd__decap_3
XFILLER_116_617 VGND VGND VPWR VPWR sky130_fd_sc_hd__decap_3
XFILLER_6_251 VGND VGND VPWR VPWR sky130_fd_sc_hd__fill_1
Xhold708 _6956_/Q VGND VGND VPWR VPWR _6956_/D sky130_fd_sc_hd__dlygate4sd3_1
Xhold719 _6838_/Q VGND VGND VPWR VPWR _6838_/D sky130_fd_sc_hd__dlygate4sd3_1
XFILLER_115_116 VGND VGND VPWR VPWR sky130_fd_sc_hd__decap_3
XFILLER_115_149 VGND VGND VPWR VPWR sky130_fd_sc_hd__decap_3
XFILLER_34_3 VGND VGND VPWR VPWR sky130_fd_sc_hd__fill_2
XFILLER_69_214 VGND VGND VPWR VPWR sky130_fd_sc_hd__decap_3
XFILLER_69_225 VGND VGND VPWR VPWR sky130_fd_sc_hd__decap_3
XFILLER_97_523 VGND VGND VPWR VPWR sky130_fd_sc_hd__decap_3
X_5120_ _5120_/A _5120_/B VGND VGND VPWR VPWR _6984_/D sky130_fd_sc_hd__nor2_2
XFILLER_111_333 VGND VGND VPWR VPWR sky130_fd_sc_hd__decap_3
XFILLER_111_344 VGND VGND VPWR VPWR sky130_fd_sc_hd__decap_3
XFILLER_57_409 VGND VGND VPWR VPWR sky130_fd_sc_hd__decap_3
XFILLER_69_269 VGND VGND VPWR VPWR sky130_fd_sc_hd__decap_3
XFILLER_97_556 VGND VGND VPWR VPWR sky130_fd_sc_hd__decap_3
XFILLER_97_567 VGND VGND VPWR VPWR sky130_fd_sc_hd__decap_3
X_5051_ _5073_/A _5050_/X _5054_/A VGND VGND VPWR VPWR _5051_/X sky130_fd_sc_hd__a21o_2
XFILLER_38_601 VGND VGND VPWR VPWR sky130_fd_sc_hd__decap_3
XFILLER_111_399 VGND VGND VPWR VPWR sky130_fd_sc_hd__decap_3
XFILLER_37_122 VGND VGND VPWR VPWR sky130_fd_sc_hd__decap_3
XFILLER_38_634 VGND VGND VPWR VPWR sky130_fd_sc_hd__decap_3
XFILLER_38_645 VGND VGND VPWR VPWR sky130_fd_sc_hd__decap_3
XTAP_TAPCELL_ROW_88_1310 VGND VPWR sky130_fd_sc_hd__tapvpwrvgnd_1
XFILLER_37_144 VGND VGND VPWR VPWR sky130_fd_sc_hd__decap_3
XFILLER_38_678 VGND VGND VPWR VPWR sky130_fd_sc_hd__decap_3
XFILLER_53_615 VGND VGND VPWR VPWR sky130_fd_sc_hd__fill_1
XFILLER_65_464 VGND VGND VPWR VPWR sky130_fd_sc_hd__fill_1
XFILLER_111_18 VGND VGND VPWR VPWR sky130_fd_sc_hd__decap_3
XFILLER_18_380 VGND VGND VPWR VPWR sky130_fd_sc_hd__fill_1
XFILLER_37_199 VGND VGND VPWR VPWR sky130_fd_sc_hd__fill_2
XFILLER_53_626 VGND VGND VPWR VPWR sky130_fd_sc_hd__decap_3
XPHY_EDGE_ROW_9_Left_126 VGND VGND VPWR VPWR sky130_fd_sc_hd__decap_3
XFILLER_52_136 VGND VGND VPWR VPWR sky130_fd_sc_hd__decap_3
XFILLER_53_659 VGND VGND VPWR VPWR sky130_fd_sc_hd__decap_3
XFILLER_80_445 VGND VGND VPWR VPWR sky130_fd_sc_hd__decap_3
XFILLER_40_309 VGND VGND VPWR VPWR sky130_fd_sc_hd__decap_3
X_4904_ _4903_/A _4904_/B VGND VGND VPWR VPWR _4904_/X sky130_fd_sc_hd__and2b_2
XTAP_TAPCELL_ROW_23_529 VGND VPWR sky130_fd_sc_hd__tapvpwrvgnd_1
XFILLER_21_556 VGND VGND VPWR VPWR sky130_fd_sc_hd__decap_3
X_4835_ _4467_/B _3709_/X _4832_/X _4834_/Y VGND VGND VPWR VPWR _4835_/X sky130_fd_sc_hd__a31o_2
XFILLER_21_567 VGND VGND VPWR VPWR sky130_fd_sc_hd__decap_3
X_4766_ _4766_/A VGND VGND VPWR VPWR _4766_/Y sky130_fd_sc_hd__inv_2
X_6505_ _6640_/A VGND VGND VPWR VPWR _6505_/Y sky130_fd_sc_hd__inv_2
XFILLER_106_105 VGND VGND VPWR VPWR sky130_fd_sc_hd__decap_3
XFILLER_107_606 VGND VGND VPWR VPWR sky130_fd_sc_hd__decap_3
XFILLER_107_617 VGND VGND VPWR VPWR sky130_fd_sc_hd__decap_3
X_4697_ _5670_/A _6984_/Q _5670_/B VGND VGND VPWR VPWR _5120_/A sky130_fd_sc_hd__and3_2
XFILLER_105_9 VGND VGND VPWR VPWR sky130_fd_sc_hd__decap_3
X_6436_ _6628_/A VGND VGND VPWR VPWR _6436_/Y sky130_fd_sc_hd__inv_2
XFILLER_115_650 VGND VGND VPWR VPWR sky130_fd_sc_hd__decap_3
X_6367_ _6596_/A VGND VGND VPWR VPWR _6367_/Y sky130_fd_sc_hd__inv_2
X_3579_ _7220_/Q _4284_/A2 _3987_/S _7188_/Q VGND VGND VPWR VPWR _3579_/X sky130_fd_sc_hd__a22o_2
XFILLER_114_193 VGND VGND VPWR VPWR sky130_fd_sc_hd__decap_3
XFILLER_88_545 VGND VGND VPWR VPWR sky130_fd_sc_hd__decap_3
X_6298_ _6581_/A VGND VGND VPWR VPWR _6298_/Y sky130_fd_sc_hd__inv_2
XFILLER_29_57 VGND VGND VPWR VPWR sky130_fd_sc_hd__decap_3
XFILLER_29_612 VGND VGND VPWR VPWR sky130_fd_sc_hd__decap_3
XFILLER_88_578 VGND VGND VPWR VPWR sky130_fd_sc_hd__decap_3
XFILLER_88_589 VGND VGND VPWR VPWR sky130_fd_sc_hd__decap_3
X_5249_ _5249_/A0 _4878_/X _5262_/S VGND VGND VPWR VPWR _7205_/D sky130_fd_sc_hd__mux2_2
XFILLER_28_122 VGND VGND VPWR VPWR sky130_fd_sc_hd__fill_1
XFILLER_29_623 VGND VGND VPWR VPWR sky130_fd_sc_hd__decap_3
XFILLER_29_656 VGND VGND VPWR VPWR sky130_fd_sc_hd__decap_3
XFILLER_29_79 VGND VGND VPWR VPWR sky130_fd_sc_hd__decap_3
XFILLER_75_228 VGND VGND VPWR VPWR sky130_fd_sc_hd__decap_3
XFILLER_16_306 VGND VGND VPWR VPWR sky130_fd_sc_hd__fill_2
XFILLER_28_144 VGND VGND VPWR VPWR sky130_fd_sc_hd__decap_3
XFILLER_44_604 VGND VGND VPWR VPWR sky130_fd_sc_hd__decap_3
XFILLER_56_453 VGND VGND VPWR VPWR sky130_fd_sc_hd__decap_3
XFILLER_90_209 VGND VGND VPWR VPWR sky130_fd_sc_hd__decap_3
XTAP_TAPCELL_ROW_3_287 VGND VPWR sky130_fd_sc_hd__tapvpwrvgnd_1
XFILLER_28_177 VGND VGND VPWR VPWR sky130_fd_sc_hd__decap_3
XFILLER_44_637 VGND VGND VPWR VPWR sky130_fd_sc_hd__decap_3
XFILLER_44_648 VGND VGND VPWR VPWR sky130_fd_sc_hd__decap_3
XFILLER_56_486 VGND VGND VPWR VPWR sky130_fd_sc_hd__decap_3
XFILLER_101_51 VGND VGND VPWR VPWR sky130_fd_sc_hd__decap_3
XFILLER_24_350 VGND VGND VPWR VPWR sky130_fd_sc_hd__decap_3
XFILLER_31_309 VGND VGND VPWR VPWR sky130_fd_sc_hd__decap_3
XFILLER_43_169 VGND VGND VPWR VPWR sky130_fd_sc_hd__decap_3
XFILLER_52_681 VGND VGND VPWR VPWR sky130_fd_sc_hd__decap_3
XFILLER_12_523 VGND VGND VPWR VPWR sky130_fd_sc_hd__decap_3
XFILLER_12_545 VGND VGND VPWR VPWR sky130_fd_sc_hd__decap_3
XTAP_TAPCELL_ROW_104_1498 VGND VPWR sky130_fd_sc_hd__tapvpwrvgnd_1
XFILLER_12_578 VGND VGND VPWR VPWR sky130_fd_sc_hd__decap_3
XFILLER_12_589 VGND VGND VPWR VPWR sky130_fd_sc_hd__decap_3
XFILLER_61_77 VGND VGND VPWR VPWR sky130_fd_sc_hd__decap_3
XFILLER_113_609 VGND VGND VPWR VPWR sky130_fd_sc_hd__decap_3
XFILLER_106_672 VGND VGND VPWR VPWR sky130_fd_sc_hd__decap_3
XFILLER_3_265 VGND VGND VPWR VPWR sky130_fd_sc_hd__fill_1
XTAP_TAPCELL_ROW_72_1111 VGND VPWR sky130_fd_sc_hd__tapvpwrvgnd_1
XFILLER_79_545 VGND VGND VPWR VPWR sky130_fd_sc_hd__decap_3
XFILLER_79_567 VGND VGND VPWR VPWR sky130_fd_sc_hd__decap_3
XFILLER_94_526 VGND VGND VPWR VPWR sky130_fd_sc_hd__decap_3
XFILLER_86_96 VGND VGND VPWR VPWR sky130_fd_sc_hd__decap_3
XFILLER_94_548 VGND VGND VPWR VPWR sky130_fd_sc_hd__decap_3
XFILLER_35_615 VGND VGND VPWR VPWR sky130_fd_sc_hd__fill_1
XFILLER_35_626 VGND VGND VPWR VPWR sky130_fd_sc_hd__decap_3
XFILLER_74_283 VGND VGND VPWR VPWR sky130_fd_sc_hd__decap_3
XFILLER_35_659 VGND VGND VPWR VPWR sky130_fd_sc_hd__decap_3
XFILLER_50_607 VGND VGND VPWR VPWR sky130_fd_sc_hd__decap_3
XFILLER_62_445 VGND VGND VPWR VPWR sky130_fd_sc_hd__decap_3
XFILLER_74_294 VGND VGND VPWR VPWR sky130_fd_sc_hd__decap_3
XFILLER_22_309 VGND VGND VPWR VPWR sky130_fd_sc_hd__decap_3
XTAP_TAPCELL_ROW_83_1251 VGND VPWR sky130_fd_sc_hd__tapvpwrvgnd_1
X_4620_ _4620_/A _5003_/A _4987_/A _5032_/A VGND VGND VPWR VPWR _4624_/B sky130_fd_sc_hd__and4_4
XFILLER_116_414 VGND VGND VPWR VPWR sky130_fd_sc_hd__decap_3
XFILLER_116_436 VGND VGND VPWR VPWR sky130_fd_sc_hd__decap_3
XFILLER_7_582 VGND VGND VPWR VPWR sky130_fd_sc_hd__decap_3
X_7270_ _7395_/CLK _7270_/D _6550_/Y VGND VGND VPWR VPWR _7270_/Q sky130_fd_sc_hd__dfrtp_2
X_4482_ _7338_/Q _4482_/A1 _4491_/S VGND VGND VPWR VPWR _7338_/D sky130_fd_sc_hd__mux2_2
X_3502_ _3502_/A _3502_/B _3485_/C VGND VGND VPWR VPWR _3502_/X sky130_fd_sc_hd__or3b_2
XFILLER_89_309 VGND VGND VPWR VPWR sky130_fd_sc_hd__decap_3
XFILLER_103_119 VGND VGND VPWR VPWR sky130_fd_sc_hd__decap_3
XTAP_TAPCELL_ROW_94_1380 VGND VPWR sky130_fd_sc_hd__tapvpwrvgnd_1
XFILLER_106_29 VGND VGND VPWR VPWR sky130_fd_sc_hd__decap_3
XFILLER_112_631 VGND VGND VPWR VPWR sky130_fd_sc_hd__decap_3
X_5103_ _5146_/B1 _5047_/Y _5099_/X _5102_/X VGND VGND VPWR VPWR _5660_/C sky130_fd_sc_hd__a31oi_2
X_3364_ _3362_/X _5294_/B _3371_/A VGND VGND VPWR VPWR _3399_/B sky130_fd_sc_hd__a21boi_2
XFILLER_112_675 VGND VGND VPWR VPWR sky130_fd_sc_hd__decap_3
Xhold1205 _7292_/Q VGND VGND VPWR VPWR _4577_/A sky130_fd_sc_hd__dlygate4sd3_1
Xhold1216 _7285_/Q VGND VGND VPWR VPWR _4591_/A sky130_fd_sc_hd__dlygate4sd3_1
XFILLER_85_548 VGND VGND VPWR VPWR sky130_fd_sc_hd__decap_3
Xhold1227 _7123_/Q VGND VGND VPWR VPWR _5421_/A0 sky130_fd_sc_hd__dlygate4sd3_1
X_5034_ _4811_/C _5031_/X _5032_/Y _4969_/B _5033_/X VGND VGND VPWR VPWR _5658_/B
+ sky130_fd_sc_hd__a221o_2
XFILLER_26_604 VGND VGND VPWR VPWR sky130_fd_sc_hd__decap_3
XFILLER_38_442 VGND VGND VPWR VPWR sky130_fd_sc_hd__decap_3
XFILLER_65_250 VGND VGND VPWR VPWR sky130_fd_sc_hd__decap_3
XFILLER_72_209 VGND VGND VPWR VPWR sky130_fd_sc_hd__decap_3
XTAP_TAPCELL_ROW_56_919 VGND VPWR sky130_fd_sc_hd__tapvpwrvgnd_1
XFILLER_26_637 VGND VGND VPWR VPWR sky130_fd_sc_hd__decap_3
XFILLER_26_648 VGND VGND VPWR VPWR sky130_fd_sc_hd__decap_3
XFILLER_38_486 VGND VGND VPWR VPWR sky130_fd_sc_hd__fill_2
XFILLER_93_570 VGND VGND VPWR VPWR sky130_fd_sc_hd__decap_3
XTAP_TAPCELL_ROW_0_235 VGND VPWR sky130_fd_sc_hd__tapvpwrvgnd_1
XFILLER_25_147 VGND VGND VPWR VPWR sky130_fd_sc_hd__decap_3
XFILLER_53_445 VGND VGND VPWR VPWR sky130_fd_sc_hd__decap_3
XFILLER_53_467 VGND VGND VPWR VPWR sky130_fd_sc_hd__decap_3
XFILLER_80_242 VGND VGND VPWR VPWR sky130_fd_sc_hd__decap_3
X_6985_ _7398_/CLK _6985_/D _6265_/Y VGND VGND VPWR VPWR _6985_/Q sky130_fd_sc_hd__dfrtp_2
XTAP_TAPCELL_ROW_0_257 VGND VPWR sky130_fd_sc_hd__tapvpwrvgnd_1
XTAP_TAPCELL_ROW_0_246 VGND VPWR sky130_fd_sc_hd__tapvpwrvgnd_1
XFILLER_25_169 VGND VGND VPWR VPWR sky130_fd_sc_hd__fill_1
XFILLER_41_629 VGND VGND VPWR VPWR sky130_fd_sc_hd__decap_3
XFILLER_80_253 VGND VGND VPWR VPWR sky130_fd_sc_hd__decap_3
XTAP_TAPCELL_ROW_36_687 VGND VPWR sky130_fd_sc_hd__tapvpwrvgnd_1
XFILLER_34_681 VGND VGND VPWR VPWR sky130_fd_sc_hd__decap_3
XFILLER_80_286 VGND VGND VPWR VPWR sky130_fd_sc_hd__decap_3
XFILLER_21_386 VGND VGND VPWR VPWR sky130_fd_sc_hd__decap_3
X_4818_ _7002_/Q _4834_/A VGND VGND VPWR VPWR _4818_/Y sky130_fd_sc_hd__nand2_2
XFILLER_31_47 VGND VGND VPWR VPWR sky130_fd_sc_hd__fill_1
XFILLER_5_508 VGND VGND VPWR VPWR sky130_fd_sc_hd__decap_3
X_4749_ _7006_/Q _4749_/B VGND VGND VPWR VPWR _4750_/C sky130_fd_sc_hd__nor2_2
XFILLER_107_447 VGND VGND VPWR VPWR sky130_fd_sc_hd__fill_1
XFILLER_103_6 VGND VGND VPWR VPWR sky130_fd_sc_hd__decap_3
XFILLER_107_458 VGND VGND VPWR VPWR sky130_fd_sc_hd__decap_3
X_6419_ _6614_/A VGND VGND VPWR VPWR _6419_/Y sky130_fd_sc_hd__inv_2
X_7399_ _7405_/CLK _7399_/D _6679_/Y VGND VGND VPWR VPWR _7399_/Q sky130_fd_sc_hd__dfrtp_2
XFILLER_0_213 VGND VGND VPWR VPWR sky130_fd_sc_hd__decap_3
XFILLER_0_235 VGND VGND VPWR VPWR sky130_fd_sc_hd__decap_3
XFILLER_103_620 VGND VGND VPWR VPWR sky130_fd_sc_hd__decap_3
XFILLER_103_653 VGND VGND VPWR VPWR sky130_fd_sc_hd__decap_3
XFILLER_115_491 VGND VGND VPWR VPWR sky130_fd_sc_hd__decap_3
XTAP_TAPCELL_ROW_8_346 VGND VPWR sky130_fd_sc_hd__tapvpwrvgnd_1
XFILLER_0_279 VGND VGND VPWR VPWR sky130_fd_sc_hd__fill_1
XFILLER_102_130 VGND VGND VPWR VPWR sky130_fd_sc_hd__decap_3
XFILLER_102_152 VGND VGND VPWR VPWR sky130_fd_sc_hd__decap_3
XFILLER_48_206 VGND VGND VPWR VPWR sky130_fd_sc_hd__decap_3
XFILLER_102_185 VGND VGND VPWR VPWR sky130_fd_sc_hd__fill_1
XFILLER_48_228 VGND VGND VPWR VPWR sky130_fd_sc_hd__decap_3
XFILLER_76_548 VGND VGND VPWR VPWR sky130_fd_sc_hd__decap_3
XFILLER_17_615 VGND VGND VPWR VPWR sky130_fd_sc_hd__fill_1
XFILLER_17_626 VGND VGND VPWR VPWR sky130_fd_sc_hd__decap_3
XFILLER_29_475 VGND VGND VPWR VPWR sky130_fd_sc_hd__decap_3
XFILLER_56_88 VGND VGND VPWR VPWR sky130_fd_sc_hd__fill_1
XFILLER_84_581 VGND VGND VPWR VPWR sky130_fd_sc_hd__decap_3
XFILLER_84_592 VGND VGND VPWR VPWR sky130_fd_sc_hd__decap_3
XTAP_TAPCELL_ROW_106_1527 VGND VPWR sky130_fd_sc_hd__tapvpwrvgnd_1
XFILLER_112_50 VGND VGND VPWR VPWR sky130_fd_sc_hd__decap_3
XFILLER_17_659 VGND VGND VPWR VPWR sky130_fd_sc_hd__decap_3
XFILLER_56_294 VGND VGND VPWR VPWR sky130_fd_sc_hd__decap_3
XFILLER_112_83 VGND VGND VPWR VPWR sky130_fd_sc_hd__fill_1
XFILLER_32_607 VGND VGND VPWR VPWR sky130_fd_sc_hd__decap_3
XFILLER_72_32 VGND VGND VPWR VPWR sky130_fd_sc_hd__decap_3
XFILLER_24_180 VGND VGND VPWR VPWR sky130_fd_sc_hd__fill_1
XFILLER_40_640 VGND VGND VPWR VPWR sky130_fd_sc_hd__decap_3
XFILLER_40_651 VGND VGND VPWR VPWR sky130_fd_sc_hd__decap_3
XFILLER_40_684 VGND VGND VPWR VPWR sky130_fd_sc_hd__decap_3
XFILLER_8_368 VGND VGND VPWR VPWR sky130_fd_sc_hd__fill_2
XFILLER_68_9 VGND VGND VPWR VPWR sky130_fd_sc_hd__decap_3
XFILLER_21_80 VGND VGND VPWR VPWR sky130_fd_sc_hd__decap_3
XFILLER_113_417 VGND VGND VPWR VPWR sky130_fd_sc_hd__decap_3
XFILLER_4_563 VGND VGND VPWR VPWR sky130_fd_sc_hd__decap_3
XFILLER_99_629 VGND VGND VPWR VPWR sky130_fd_sc_hd__decap_3
XFILLER_106_480 VGND VGND VPWR VPWR sky130_fd_sc_hd__decap_3
XFILLER_79_320 VGND VGND VPWR VPWR sky130_fd_sc_hd__decap_3
XFILLER_98_139 VGND VGND VPWR VPWR sky130_fd_sc_hd__fill_1
XFILLER_97_73 VGND VGND VPWR VPWR sky130_fd_sc_hd__fill_1
XFILLER_94_378 VGND VGND VPWR VPWR sky130_fd_sc_hd__fill_1
XFILLER_47_272 VGND VGND VPWR VPWR sky130_fd_sc_hd__decap_3
XFILLER_75_570 VGND VGND VPWR VPWR sky130_fd_sc_hd__decap_3
XFILLER_90_551 VGND VGND VPWR VPWR sky130_fd_sc_hd__decap_3
XFILLER_23_629 VGND VGND VPWR VPWR sky130_fd_sc_hd__decap_3
XFILLER_35_467 VGND VGND VPWR VPWR sky130_fd_sc_hd__decap_3
XFILLER_62_264 VGND VGND VPWR VPWR sky130_fd_sc_hd__decap_3
XFILLER_90_584 VGND VGND VPWR VPWR sky130_fd_sc_hd__decap_3
X_6770_ _6959_/CLK _6770_/D VGND VGND VPWR VPWR _6770_/Q sky130_fd_sc_hd__dfxtp_2
XFILLER_16_681 VGND VGND VPWR VPWR sky130_fd_sc_hd__decap_3
XFILLER_90_595 VGND VGND VPWR VPWR sky130_fd_sc_hd__decap_3
X_5721_ _7366_/Q hold987/X _5737_/S VGND VGND VPWR VPWR _6710_/D sky130_fd_sc_hd__mux2_2
XTAP_TAPCELL_ROW_33_646 VGND VPWR sky130_fd_sc_hd__tapvpwrvgnd_1
XFILLER_15_191 VGND VGND VPWR VPWR sky130_fd_sc_hd__decap_3
XFILLER_31_662 VGND VGND VPWR VPWR sky130_fd_sc_hd__decap_3
XTAP_TAPCELL_ROW_61_988 VGND VPWR sky130_fd_sc_hd__tapvpwrvgnd_1
XPHY_EDGE_ROW_99_Left_216 VGND VGND VPWR VPWR sky130_fd_sc_hd__decap_3
XFILLER_31_673 VGND VGND VPWR VPWR sky130_fd_sc_hd__decap_3
X_5652_ _5664_/A VGND VGND VPWR VPWR _5652_/Y sky130_fd_sc_hd__inv_2
X_5583_ _5583_/A0 _5094_/X _5593_/B VGND VGND VPWR VPWR _7037_/D sky130_fd_sc_hd__mux2_2
X_4603_ hold988/X _4591_/B _3487_/X VGND VGND VPWR VPWR _7279_/D sky130_fd_sc_hd__a21o_2
XFILLER_116_200 VGND VGND VPWR VPWR sky130_fd_sc_hd__fill_2
X_7322_ _7322_/CLK _7322_/D _6602_/Y VGND VGND VPWR VPWR _7322_/Q sky130_fd_sc_hd__dfrtp_2
X_4534_ _4534_/A0 _4601_/A0 _4534_/S VGND VGND VPWR VPWR _7312_/D sky130_fd_sc_hd__mux2_2
XFILLER_116_244 VGND VGND VPWR VPWR sky130_fd_sc_hd__decap_3
XFILLER_104_406 VGND VGND VPWR VPWR sky130_fd_sc_hd__fill_2
XFILLER_89_106 VGND VGND VPWR VPWR sky130_fd_sc_hd__decap_3
XFILLER_89_128 VGND VGND VPWR VPWR sky130_fd_sc_hd__decap_3
X_7253_ _7349_/CLK _7253_/D _6533_/Y VGND VGND VPWR VPWR _7253_/Q sky130_fd_sc_hd__dfrtp_2
X_4465_ _5655_/B _5655_/C VGND VGND VPWR VPWR _5650_/A sky130_fd_sc_hd__nor2_2
X_7184_ _7311_/CLK _7184_/D _6464_/Y VGND VGND VPWR VPWR _7184_/Q sky130_fd_sc_hd__dfrtp_2
X_4396_ _4396_/A _4444_/B VGND VGND VPWR VPWR _4648_/A sky130_fd_sc_hd__nor2_2
XFILLER_98_651 VGND VGND VPWR VPWR sky130_fd_sc_hd__decap_3
XFILLER_98_640 VGND VGND VPWR VPWR sky130_fd_sc_hd__decap_3
XFILLER_100_601 VGND VGND VPWR VPWR sky130_fd_sc_hd__decap_3
XFILLER_85_301 VGND VGND VPWR VPWR sky130_fd_sc_hd__decap_3
XFILLER_97_150 VGND VGND VPWR VPWR sky130_fd_sc_hd__decap_3
X_3347_ _5640_/B _3509_/B VGND VGND VPWR VPWR _3420_/A sky130_fd_sc_hd__or2_2
XTAP_TAPCELL_ROW_5_316 VGND VPWR sky130_fd_sc_hd__tapvpwrvgnd_1
XFILLER_98_684 VGND VGND VPWR VPWR sky130_fd_sc_hd__decap_3
XFILLER_100_634 VGND VGND VPWR VPWR sky130_fd_sc_hd__decap_3
XFILLER_100_645 VGND VGND VPWR VPWR sky130_fd_sc_hd__decap_3
XFILLER_112_472 VGND VGND VPWR VPWR sky130_fd_sc_hd__decap_3
XFILLER_112_483 VGND VGND VPWR VPWR sky130_fd_sc_hd__decap_3
Xhold1002 _7198_/Q VGND VGND VPWR VPWR _5264_/A0 sky130_fd_sc_hd__dlygate4sd3_1
Xhold1013 _7201_/Q VGND VGND VPWR VPWR _5258_/A0 sky130_fd_sc_hd__dlygate4sd3_1
Xhold1024 _7214_/Q VGND VGND VPWR VPWR _5232_/A0 sky130_fd_sc_hd__dlygate4sd3_1
XFILLER_100_678 VGND VGND VPWR VPWR sky130_fd_sc_hd__decap_3
Xhold1035 _7261_/Q VGND VGND VPWR VPWR _5012_/A0 sky130_fd_sc_hd__dlygate4sd3_1
Xhold1046 _7269_/Q VGND VGND VPWR VPWR _4879_/A0 sky130_fd_sc_hd__dlygate4sd3_1
Xhold1057 _7275_/Q VGND VGND VPWR VPWR _4772_/A0 sky130_fd_sc_hd__dlygate4sd3_1
X_5017_ _5018_/A _5017_/B VGND VGND VPWR VPWR _5017_/Y sky130_fd_sc_hd__xnor2_2
XFILLER_26_401 VGND VGND VPWR VPWR sky130_fd_sc_hd__decap_3
XFILLER_38_261 VGND VGND VPWR VPWR sky130_fd_sc_hd__decap_3
XFILLER_66_581 VGND VGND VPWR VPWR sky130_fd_sc_hd__decap_3
Xhold1068 _7397_/Q VGND VGND VPWR VPWR _3754_/A1 sky130_fd_sc_hd__dlygate4sd3_1
Xhold1079 _7233_/Q VGND VGND VPWR VPWR _5190_/A sky130_fd_sc_hd__dlygate4sd3_1
XFILLER_26_445 VGND VGND VPWR VPWR sky130_fd_sc_hd__decap_3
XFILLER_38_294 VGND VGND VPWR VPWR sky130_fd_sc_hd__decap_3
XFILLER_66_592 VGND VGND VPWR VPWR sky130_fd_sc_hd__decap_3
XFILLER_14_607 VGND VGND VPWR VPWR sky130_fd_sc_hd__decap_3
XFILLER_53_264 VGND VGND VPWR VPWR sky130_fd_sc_hd__decap_3
XFILLER_81_551 VGND VGND VPWR VPWR sky130_fd_sc_hd__decap_3
XFILLER_81_573 VGND VGND VPWR VPWR sky130_fd_sc_hd__decap_3
X_6968_ _6968_/CLK _6968_/D VGND VGND VPWR VPWR _6968_/Q sky130_fd_sc_hd__dfxtp_2
XFILLER_22_640 VGND VGND VPWR VPWR sky130_fd_sc_hd__decap_3
XFILLER_22_651 VGND VGND VPWR VPWR sky130_fd_sc_hd__decap_3
X_6899_ clkload6/A _6899_/D VGND VGND VPWR VPWR _6899_/Q sky130_fd_sc_hd__dfxtp_2
XFILLER_22_684 VGND VGND VPWR VPWR sky130_fd_sc_hd__decap_3
XFILLER_42_46 VGND VGND VPWR VPWR sky130_fd_sc_hd__fill_1
XTAP_TAPCELL_ROW_101_1468 VGND VPWR sky130_fd_sc_hd__tapvpwrvgnd_1
XFILLER_107_233 VGND VGND VPWR VPWR sky130_fd_sc_hd__fill_2
XFILLER_101_3 VGND VGND VPWR VPWR sky130_fd_sc_hd__decap_3
XFILLER_1_511 VGND VGND VPWR VPWR sky130_fd_sc_hd__decap_3
XFILLER_1_544 VGND VGND VPWR VPWR sky130_fd_sc_hd__decap_3
XFILLER_3_18 VGND VGND VPWR VPWR sky130_fd_sc_hd__decap_3
Xhold880 _7108_/Q VGND VGND VPWR VPWR _7108_/D sky130_fd_sc_hd__dlygate4sd3_1
Xhold891 _7103_/Q VGND VGND VPWR VPWR _7103_/D sky130_fd_sc_hd__dlygate4sd3_1
XFILLER_107_83 VGND VGND VPWR VPWR sky130_fd_sc_hd__fill_2
XFILLER_1_577 VGND VGND VPWR VPWR sky130_fd_sc_hd__decap_3
XFILLER_76_301 VGND VGND VPWR VPWR sky130_fd_sc_hd__fill_1
XFILLER_89_662 VGND VGND VPWR VPWR sky130_fd_sc_hd__decap_3
XFILLER_89_673 VGND VGND VPWR VPWR sky130_fd_sc_hd__decap_3
XFILLER_103_483 VGND VGND VPWR VPWR sky130_fd_sc_hd__decap_3
XFILLER_107_94 VGND VGND VPWR VPWR sky130_fd_sc_hd__decap_3
XTAP_TAPCELL_ROW_112_1597 VGND VPWR sky130_fd_sc_hd__tapvpwrvgnd_1
XFILLER_29_261 VGND VGND VPWR VPWR sky130_fd_sc_hd__decap_3
XFILLER_36_209 VGND VGND VPWR VPWR sky130_fd_sc_hd__decap_3
XFILLER_57_570 VGND VGND VPWR VPWR sky130_fd_sc_hd__decap_3
XFILLER_64_529 VGND VGND VPWR VPWR sky130_fd_sc_hd__decap_3
XFILLER_17_434 VGND VGND VPWR VPWR sky130_fd_sc_hd__decap_3
XFILLER_91_337 VGND VGND VPWR VPWR sky130_fd_sc_hd__decap_3
XFILLER_17_489 VGND VGND VPWR VPWR sky130_fd_sc_hd__decap_3
XFILLER_44_253 VGND VGND VPWR VPWR sky130_fd_sc_hd__fill_1
XFILLER_72_562 VGND VGND VPWR VPWR sky130_fd_sc_hd__decap_3
XTAP_TAPCELL_ROW_67_1054 VGND VPWR sky130_fd_sc_hd__tapvpwrvgnd_1
XFILLER_16_80 VGND VGND VPWR VPWR sky130_fd_sc_hd__decap_3
XFILLER_32_448 VGND VGND VPWR VPWR sky130_fd_sc_hd__decap_3
XFILLER_44_286 VGND VGND VPWR VPWR sky130_fd_sc_hd__decap_3
XFILLER_72_595 VGND VGND VPWR VPWR sky130_fd_sc_hd__decap_3
XTAP_TAPCELL_ROW_80_1210 VGND VPWR sky130_fd_sc_hd__tapvpwrvgnd_1
XFILLER_13_662 VGND VGND VPWR VPWR sky130_fd_sc_hd__decap_3
XFILLER_16_91 VGND VGND VPWR VPWR sky130_fd_sc_hd__fill_2
XFILLER_9_600 VGND VGND VPWR VPWR sky130_fd_sc_hd__decap_3
XFILLER_13_673 VGND VGND VPWR VPWR sky130_fd_sc_hd__decap_3
XTAP_TAPCELL_ROW_30_616 VGND VPWR sky130_fd_sc_hd__tapvpwrvgnd_1
XFILLER_9_644 VGND VGND VPWR VPWR sky130_fd_sc_hd__decap_3
XFILLER_40_492 VGND VGND VPWR VPWR sky130_fd_sc_hd__decap_3
XFILLER_66_6 VGND VGND VPWR VPWR sky130_fd_sc_hd__decap_3
XFILLER_9_688 VGND VGND VPWR VPWR sky130_fd_sc_hd__decap_3
XTAP_TAPCELL_ROW_10_373 VGND VPWR sky130_fd_sc_hd__tapvpwrvgnd_1
XFILLER_113_214 VGND VGND VPWR VPWR sky130_fd_sc_hd__decap_3
XFILLER_4_360 VGND VGND VPWR VPWR sky130_fd_sc_hd__decap_3
XTAP_TAPCELL_ROW_78_1183 VGND VPWR sky130_fd_sc_hd__tapvpwrvgnd_1
XFILLER_99_404 VGND VGND VPWR VPWR sky130_fd_sc_hd__decap_3
XFILLER_113_225 VGND VGND VPWR VPWR sky130_fd_sc_hd__fill_2
X_4250_ _7101_/Q _4351_/A2 _4352_/B1 _7165_/Q VGND VGND VPWR VPWR _4250_/X sky130_fd_sc_hd__a22o_2
XFILLER_113_269 VGND VGND VPWR VPWR sky130_fd_sc_hd__fill_1
XFILLER_86_109 VGND VGND VPWR VPWR sky130_fd_sc_hd__decap_3
X_4181_ _7200_/Q _3968_/S _4346_/B1 _7392_/Q VGND VGND VPWR VPWR _4181_/X sky130_fd_sc_hd__a22o_2
XFILLER_79_172 VGND VGND VPWR VPWR sky130_fd_sc_hd__decap_3
XFILLER_95_632 VGND VGND VPWR VPWR sky130_fd_sc_hd__decap_3
XFILLER_67_345 VGND VGND VPWR VPWR sky130_fd_sc_hd__decap_3
XFILLER_95_665 VGND VGND VPWR VPWR sky130_fd_sc_hd__decap_3
XFILLER_95_676 VGND VGND VPWR VPWR sky130_fd_sc_hd__decap_3
XFILLER_48_570 VGND VGND VPWR VPWR sky130_fd_sc_hd__decap_3
XFILLER_67_389 VGND VGND VPWR VPWR sky130_fd_sc_hd__decap_3
XFILLER_82_315 VGND VGND VPWR VPWR sky130_fd_sc_hd__decap_3
XTAP_TAPCELL_ROW_38_705 VGND VPWR sky130_fd_sc_hd__tapvpwrvgnd_1
XFILLER_48_592 VGND VGND VPWR VPWR sky130_fd_sc_hd__decap_3
XFILLER_63_551 VGND VGND VPWR VPWR sky130_fd_sc_hd__decap_3
XFILLER_63_573 VGND VGND VPWR VPWR sky130_fd_sc_hd__decap_3
X_6822_ _6970_/CLK _6822_/D VGND VGND VPWR VPWR _6822_/Q sky130_fd_sc_hd__dfxtp_2
XFILLER_90_392 VGND VGND VPWR VPWR sky130_fd_sc_hd__decap_3
XTAP_TAPCELL_ROW_18_473 VGND VPWR sky130_fd_sc_hd__tapvpwrvgnd_1
XTAP_TAPCELL_ROW_18_462 VGND VPWR sky130_fd_sc_hd__tapvpwrvgnd_1
XFILLER_50_256 VGND VGND VPWR VPWR sky130_fd_sc_hd__decap_3
X_6753_ clkload6/A _6753_/D VGND VGND VPWR VPWR _6753_/Q sky130_fd_sc_hd__dfxtp_2
X_6684_ _6685_/A VGND VGND VPWR VPWR _6684_/Y sky130_fd_sc_hd__inv_2
X_3896_ _3880_/X _3885_/X _3895_/X _3991_/A VGND VGND VPWR VPWR _3896_/Y sky130_fd_sc_hd__o31ai_2
X_5566_ hold992/X _4983_/A _4860_/Y VGND VGND VPWR VPWR _7051_/D sky130_fd_sc_hd__o21a_2
XFILLER_104_203 VGND VGND VPWR VPWR sky130_fd_sc_hd__decap_3
X_7305_ _7372_/CLK _7305_/D _6585_/Y VGND VGND VPWR VPWR _7305_/Q sky130_fd_sc_hd__dfrtp_2
X_4517_ _4517_/A0 _7289_/Q _4517_/S VGND VGND VPWR VPWR _7321_/D sky130_fd_sc_hd__mux2_2
X_7236_ _7332_/CLK _7236_/D _6516_/Y VGND VGND VPWR VPWR _7236_/Q sky130_fd_sc_hd__dfrtp_2
X_4448_ _4444_/X _4447_/Y _4413_/A VGND VGND VPWR VPWR _4448_/X sky130_fd_sc_hd__o21a_2
XFILLER_58_312 VGND VGND VPWR VPWR sky130_fd_sc_hd__decap_3
XFILLER_86_610 VGND VGND VPWR VPWR sky130_fd_sc_hd__decap_3
X_7167_ _7364_/CLK _7167_/D _6447_/Y VGND VGND VPWR VPWR _7167_/Q sky130_fd_sc_hd__dfrtp_2
X_4379_ _4938_/B _4379_/B VGND VGND VPWR VPWR _4937_/A sky130_fd_sc_hd__or2_2
XFILLER_98_492 VGND VGND VPWR VPWR sky130_fd_sc_hd__decap_3
XFILLER_112_280 VGND VGND VPWR VPWR sky130_fd_sc_hd__fill_2
XFILLER_86_643 VGND VGND VPWR VPWR sky130_fd_sc_hd__fill_1
XFILLER_86_654 VGND VGND VPWR VPWR sky130_fd_sc_hd__decap_3
X_7098_ _7322_/CLK _7098_/D _6378_/Y VGND VGND VPWR VPWR _7098_/Q sky130_fd_sc_hd__dfrtp_2
XFILLER_100_486 VGND VGND VPWR VPWR sky130_fd_sc_hd__decap_3
XFILLER_18_209 VGND VGND VPWR VPWR sky130_fd_sc_hd__decap_3
XFILLER_37_35 VGND VGND VPWR VPWR sky130_fd_sc_hd__decap_3
XFILLER_37_57 VGND VGND VPWR VPWR sky130_fd_sc_hd__decap_3
XFILLER_39_570 VGND VGND VPWR VPWR sky130_fd_sc_hd__decap_3
XFILLER_58_389 VGND VGND VPWR VPWR sky130_fd_sc_hd__decap_3
XFILLER_73_315 VGND VGND VPWR VPWR sky130_fd_sc_hd__decap_3
XFILLER_86_687 VGND VGND VPWR VPWR sky130_fd_sc_hd__decap_3
XFILLER_73_337 VGND VGND VPWR VPWR sky130_fd_sc_hd__decap_3
XFILLER_85_197 VGND VGND VPWR VPWR sky130_fd_sc_hd__decap_3
XFILLER_14_404 VGND VGND VPWR VPWR sky130_fd_sc_hd__decap_3
XFILLER_26_242 VGND VGND VPWR VPWR sky130_fd_sc_hd__decap_3
XFILLER_26_253 VGND VGND VPWR VPWR sky130_fd_sc_hd__decap_3
XFILLER_41_223 VGND VGND VPWR VPWR sky130_fd_sc_hd__fill_1
XFILLER_54_584 VGND VGND VPWR VPWR sky130_fd_sc_hd__decap_3
XFILLER_54_595 VGND VGND VPWR VPWR sky130_fd_sc_hd__decap_3
XFILLER_41_234 VGND VGND VPWR VPWR sky130_fd_sc_hd__decap_3
XFILLER_10_610 VGND VGND VPWR VPWR sky130_fd_sc_hd__decap_3
XFILLER_22_470 VGND VGND VPWR VPWR sky130_fd_sc_hd__decap_3
XFILLER_41_267 VGND VGND VPWR VPWR sky130_fd_sc_hd__fill_2
XFILLER_10_643 VGND VGND VPWR VPWR sky130_fd_sc_hd__fill_1
XFILLER_10_654 VGND VGND VPWR VPWR sky130_fd_sc_hd__decap_3
XFILLER_10_687 VGND VGND VPWR VPWR sky130_fd_sc_hd__decap_3
XFILLER_6_625 VGND VGND VPWR VPWR sky130_fd_sc_hd__decap_3
XFILLER_108_531 VGND VGND VPWR VPWR sky130_fd_sc_hd__fill_1
XFILLER_108_542 VGND VGND VPWR VPWR sky130_fd_sc_hd__decap_3
XFILLER_6_669 VGND VGND VPWR VPWR sky130_fd_sc_hd__decap_3
XFILLER_108_575 VGND VGND VPWR VPWR sky130_fd_sc_hd__decap_3
XTAP_TAPCELL_ROW_114_1615 VGND VPWR sky130_fd_sc_hd__tapvpwrvgnd_1
XFILLER_110_228 VGND VGND VPWR VPWR sky130_fd_sc_hd__decap_3
XFILLER_1_374 VGND VGND VPWR VPWR sky130_fd_sc_hd__decap_3
XFILLER_77_632 VGND VGND VPWR VPWR sky130_fd_sc_hd__decap_3
XFILLER_78_97 VGND VGND VPWR VPWR sky130_fd_sc_hd__decap_3
XFILLER_89_492 VGND VGND VPWR VPWR sky130_fd_sc_hd__decap_3
XFILLER_96_429 VGND VGND VPWR VPWR sky130_fd_sc_hd__decap_3
XFILLER_1_396 VGND VGND VPWR VPWR sky130_fd_sc_hd__decap_3
XFILLER_77_665 VGND VGND VPWR VPWR sky130_fd_sc_hd__decap_3
XFILLER_64_304 VGND VGND VPWR VPWR sky130_fd_sc_hd__decap_3
XFILLER_64_326 VGND VGND VPWR VPWR sky130_fd_sc_hd__decap_3
XFILLER_76_175 VGND VGND VPWR VPWR sky130_fd_sc_hd__decap_3
XFILLER_77_676 VGND VGND VPWR VPWR sky130_fd_sc_hd__decap_3
XFILLER_91_101 VGND VGND VPWR VPWR sky130_fd_sc_hd__fill_2
XFILLER_92_613 VGND VGND VPWR VPWR sky130_fd_sc_hd__decap_3
XFILLER_76_197 VGND VGND VPWR VPWR sky130_fd_sc_hd__decap_3
XFILLER_91_134 VGND VGND VPWR VPWR sky130_fd_sc_hd__decap_3
XFILLER_92_657 VGND VGND VPWR VPWR sky130_fd_sc_hd__decap_3
XFILLER_94_85 VGND VGND VPWR VPWR sky130_fd_sc_hd__fill_1
XFILLER_45_573 VGND VGND VPWR VPWR sky130_fd_sc_hd__decap_3
XFILLER_32_234 VGND VGND VPWR VPWR sky130_fd_sc_hd__decap_3
XFILLER_32_256 VGND VGND VPWR VPWR sky130_fd_sc_hd__fill_1
XTAP_TAPCELL_ROW_15_432 VGND VPWR sky130_fd_sc_hd__tapvpwrvgnd_1
XFILLER_20_418 VGND VGND VPWR VPWR sky130_fd_sc_hd__fill_2
XFILLER_32_278 VGND VGND VPWR VPWR sky130_fd_sc_hd__decap_3
XFILLER_60_576 VGND VGND VPWR VPWR sky130_fd_sc_hd__decap_3
XFILLER_60_598 VGND VGND VPWR VPWR sky130_fd_sc_hd__decap_3
X_3750_ _7398_/Q _3822_/A2 wire550/X VGND VGND VPWR VPWR _7398_/D sky130_fd_sc_hd__a21bo_2
XTAP_TAPCELL_ROW_43_763 VGND VPWR sky130_fd_sc_hd__tapvpwrvgnd_1
XFILLER_9_452 VGND VGND VPWR VPWR sky130_fd_sc_hd__fill_1
X_3681_ _3674_/Y _3926_/B1 _3925_/A2 _3676_/Y _3680_/X VGND VGND VPWR VPWR _3682_/B
+ sky130_fd_sc_hd__a221o_2
XFILLER_9_474 VGND VGND VPWR VPWR sky130_fd_sc_hd__decap_3
XFILLER_114_501 VGND VGND VPWR VPWR sky130_fd_sc_hd__decap_3
XFILLER_114_545 VGND VGND VPWR VPWR sky130_fd_sc_hd__decap_3
X_5282_ hold964/X _5238_/X _3610_/Y VGND VGND VPWR VPWR _7189_/D sky130_fd_sc_hd__a21o_2
X_4302_ _7224_/Q _4349_/B1 _4248_/A _4301_/X VGND VGND VPWR VPWR _4302_/X sky130_fd_sc_hd__a211o_2
XFILLER_99_234 VGND VGND VPWR VPWR sky130_fd_sc_hd__decap_3
XFILLER_114_578 VGND VGND VPWR VPWR sky130_fd_sc_hd__decap_3
XFILLER_59_109 VGND VGND VPWR VPWR sky130_fd_sc_hd__decap_3
X_7021_ _7328_/CLK _7021_/D _6301_/Y VGND VGND VPWR VPWR _7021_/Q sky130_fd_sc_hd__dfrtp_2
X_4233_ _7323_/Q _3989_/S _4532_/S _7291_/Q VGND VGND VPWR VPWR _4233_/X sky130_fd_sc_hd__a22o_2
XFILLER_99_267 VGND VGND VPWR VPWR sky130_fd_sc_hd__decap_3
XFILLER_99_256 VGND VGND VPWR VPWR sky130_fd_sc_hd__fill_2
XFILLER_101_217 VGND VGND VPWR VPWR sky130_fd_sc_hd__decap_3
XFILLER_101_239 VGND VGND VPWR VPWR sky130_fd_sc_hd__fill_1
XFILLER_114_589 VGND VGND VPWR VPWR sky130_fd_sc_hd__decap_3
XFILLER_68_610 VGND VGND VPWR VPWR sky130_fd_sc_hd__decap_3
XFILLER_114_18 VGND VGND VPWR VPWR sky130_fd_sc_hd__decap_3
XFILLER_114_29 VGND VGND VPWR VPWR sky130_fd_sc_hd__decap_3
XFILLER_68_643 VGND VGND VPWR VPWR sky130_fd_sc_hd__fill_1
XFILLER_68_654 VGND VGND VPWR VPWR sky130_fd_sc_hd__decap_3
X_4164_ _7105_/Q _4434_/A2 _4436_/B1 _7169_/Q VGND VGND VPWR VPWR _4164_/X sky130_fd_sc_hd__a22o_2
XFILLER_28_518 VGND VGND VPWR VPWR sky130_fd_sc_hd__decap_3
XFILLER_68_687 VGND VGND VPWR VPWR sky130_fd_sc_hd__decap_3
X_4095_ _4095_/A _4210_/B VGND VGND VPWR VPWR _4096_/B sky130_fd_sc_hd__nand2_2
XFILLER_55_337 VGND VGND VPWR VPWR sky130_fd_sc_hd__decap_3
XFILLER_55_359 VGND VGND VPWR VPWR sky130_fd_sc_hd__decap_3
XFILLER_83_635 VGND VGND VPWR VPWR sky130_fd_sc_hd__decap_3
XFILLER_83_668 VGND VGND VPWR VPWR sky130_fd_sc_hd__decap_3
XFILLER_70_318 VGND VGND VPWR VPWR sky130_fd_sc_hd__decap_3
XFILLER_82_167 VGND VGND VPWR VPWR sky130_fd_sc_hd__decap_3
XFILLER_83_679 VGND VGND VPWR VPWR sky130_fd_sc_hd__decap_3
XFILLER_23_223 VGND VGND VPWR VPWR sky130_fd_sc_hd__fill_1
XFILLER_36_584 VGND VGND VPWR VPWR sky130_fd_sc_hd__decap_3
XFILLER_36_595 VGND VGND VPWR VPWR sky130_fd_sc_hd__decap_3
Xplace381 _3874_/A VGND VGND VPWR VPWR _4791_/A1 sky130_fd_sc_hd__buf_2
Xplace370 _4248_/A VGND VGND VPWR VPWR _4347_/C1 sky130_fd_sc_hd__buf_2
X_6805_ _6941_/CLK _6805_/D VGND VGND VPWR VPWR _6805_/Q sky130_fd_sc_hd__dfxtp_2
XFILLER_51_576 VGND VGND VPWR VPWR sky130_fd_sc_hd__decap_3
Xplace392 _5642_/A VGND VGND VPWR VPWR _5666_/A sky130_fd_sc_hd__buf_2
X_6736_ clkload8/A _6736_/D VGND VGND VPWR VPWR _6736_/Q sky130_fd_sc_hd__dfxtp_2
X_4997_ _4997_/A1 _6992_/D _4983_/X _4996_/X VGND VGND VPWR VPWR _4997_/X sky130_fd_sc_hd__a211o_2
X_6667_ _6667_/A VGND VGND VPWR VPWR _6667_/Y sky130_fd_sc_hd__inv_2
X_3879_ _6747_/Q _3879_/A2 _3879_/B1 _6735_/Q _3878_/X VGND VGND VPWR VPWR _3879_/X
+ sky130_fd_sc_hd__a221o_2
X_6598_ _6630_/A VGND VGND VPWR VPWR _6598_/Y sky130_fd_sc_hd__inv_2
XFILLER_105_501 VGND VGND VPWR VPWR sky130_fd_sc_hd__decap_3
XFILLER_3_606 VGND VGND VPWR VPWR sky130_fd_sc_hd__decap_3
XFILLER_3_617 VGND VGND VPWR VPWR sky130_fd_sc_hd__decap_3
XFILLER_105_523 VGND VGND VPWR VPWR sky130_fd_sc_hd__decap_3
XFILLER_2_127 VGND VGND VPWR VPWR sky130_fd_sc_hd__decap_3
XFILLER_105_556 VGND VGND VPWR VPWR sky130_fd_sc_hd__decap_3
XFILLER_105_567 VGND VGND VPWR VPWR sky130_fd_sc_hd__decap_3
XFILLER_48_23 VGND VGND VPWR VPWR sky130_fd_sc_hd__decap_3
XFILLER_59_632 VGND VGND VPWR VPWR sky130_fd_sc_hd__decap_3
X_7219_ _7317_/CLK _7219_/D _6499_/Y VGND VGND VPWR VPWR _7219_/Q sky130_fd_sc_hd__dfrtp_2
XFILLER_59_665 VGND VGND VPWR VPWR sky130_fd_sc_hd__decap_3
XFILLER_59_676 VGND VGND VPWR VPWR sky130_fd_sc_hd__decap_3
XFILLER_74_613 VGND VGND VPWR VPWR sky130_fd_sc_hd__decap_3
XFILLER_46_326 VGND VGND VPWR VPWR sky130_fd_sc_hd__decap_3
XFILLER_64_11 VGND VGND VPWR VPWR sky130_fd_sc_hd__decap_3
XFILLER_74_657 VGND VGND VPWR VPWR sky130_fd_sc_hd__decap_3
XFILLER_46_359 VGND VGND VPWR VPWR sky130_fd_sc_hd__fill_1
XFILLER_64_44 VGND VGND VPWR VPWR sky130_fd_sc_hd__fill_1
XFILLER_73_156 VGND VGND VPWR VPWR sky130_fd_sc_hd__decap_3
XFILLER_27_573 VGND VGND VPWR VPWR sky130_fd_sc_hd__decap_3
XFILLER_42_510 VGND VGND VPWR VPWR sky130_fd_sc_hd__decap_3
XFILLER_64_88 VGND VGND VPWR VPWR sky130_fd_sc_hd__decap_3
XFILLER_82_690 VGND VGND VPWR VPWR sky130_fd_sc_hd__fill_1
XTAP_TAPCELL_ROW_64_1024 VGND VPWR sky130_fd_sc_hd__tapvpwrvgnd_1
XFILLER_14_256 VGND VGND VPWR VPWR sky130_fd_sc_hd__decap_3
XFILLER_42_554 VGND VGND VPWR VPWR sky130_fd_sc_hd__decap_3
XFILLER_54_392 VGND VGND VPWR VPWR sky130_fd_sc_hd__fill_1
XFILLER_42_587 VGND VGND VPWR VPWR sky130_fd_sc_hd__fill_1
XFILLER_42_598 VGND VGND VPWR VPWR sky130_fd_sc_hd__decap_3
Xfanout60 _6582_/A VGND VGND VPWR VPWR _6581_/A sky130_fd_sc_hd__buf_2
Xfanout71 _6462_/A VGND VGND VPWR VPWR _6558_/A sky130_fd_sc_hd__buf_1
XTAP_TAPCELL_ROW_40_733 VGND VPWR sky130_fd_sc_hd__tapvpwrvgnd_1
XFILLER_6_400 VGND VGND VPWR VPWR sky130_fd_sc_hd__fill_1
XFILLER_6_477 VGND VGND VPWR VPWR sky130_fd_sc_hd__decap_3
XFILLER_89_41 VGND VGND VPWR VPWR sky130_fd_sc_hd__decap_3
XTAP_TAPCELL_ROW_20_490 VGND VPWR sky130_fd_sc_hd__tapvpwrvgnd_1
XTAP_TAPCELL_ROW_75_1153 VGND VPWR sky130_fd_sc_hd__tapvpwrvgnd_1
XFILLER_111_526 VGND VGND VPWR VPWR sky130_fd_sc_hd__decap_3
XFILLER_2_672 VGND VGND VPWR VPWR sky130_fd_sc_hd__decap_3
XFILLER_111_559 VGND VGND VPWR VPWR sky130_fd_sc_hd__fill_1
XFILLER_37_304 VGND VGND VPWR VPWR sky130_fd_sc_hd__decap_3
XFILLER_37_337 VGND VGND VPWR VPWR sky130_fd_sc_hd__fill_1
XFILLER_65_635 VGND VGND VPWR VPWR sky130_fd_sc_hd__decap_3
XFILLER_77_495 VGND VGND VPWR VPWR sky130_fd_sc_hd__decap_3
XFILLER_92_421 VGND VGND VPWR VPWR sky130_fd_sc_hd__decap_3
XTAP_TAPCELL_ROW_48_833 VGND VPWR sky130_fd_sc_hd__tapvpwrvgnd_1
XTAP_TAPCELL_ROW_48_822 VGND VPWR sky130_fd_sc_hd__tapvpwrvgnd_1
XFILLER_18_551 VGND VGND VPWR VPWR sky130_fd_sc_hd__decap_3
XFILLER_64_167 VGND VGND VPWR VPWR sky130_fd_sc_hd__decap_3
XFILLER_65_668 VGND VGND VPWR VPWR sky130_fd_sc_hd__decap_3
XFILLER_65_679 VGND VGND VPWR VPWR sky130_fd_sc_hd__decap_3
XFILLER_80_616 VGND VGND VPWR VPWR sky130_fd_sc_hd__decap_3
XFILLER_18_584 VGND VGND VPWR VPWR sky130_fd_sc_hd__decap_3
XFILLER_18_595 VGND VGND VPWR VPWR sky130_fd_sc_hd__decap_3
XFILLER_52_318 VGND VGND VPWR VPWR sky130_fd_sc_hd__decap_3
XFILLER_52_329 VGND VGND VPWR VPWR sky130_fd_sc_hd__decap_3
X_4920_ _4920_/A _4920_/B VGND VGND VPWR VPWR _4920_/Y sky130_fd_sc_hd__xnor2_2
XTAP_TAPCELL_ROW_86_1282 VGND VPWR sky130_fd_sc_hd__tapvpwrvgnd_1
X_4851_ _4633_/A _4142_/X _4849_/Y _4850_/Y _4969_/B VGND VGND VPWR VPWR _4855_/B
+ sky130_fd_sc_hd__o311a_2
XTAP_TAPCELL_ROW_28_590 VGND VPWR sky130_fd_sc_hd__tapvpwrvgnd_1
XFILLER_33_576 VGND VGND VPWR VPWR sky130_fd_sc_hd__decap_3
XFILLER_60_362 VGND VGND VPWR VPWR sky130_fd_sc_hd__fill_2
X_3802_ _3733_/X _3794_/X _3796_/X _3746_/X _3801_/X VGND VGND VPWR VPWR _3802_/X
+ sky130_fd_sc_hd__a221o_2
XFILLER_20_226 VGND VGND VPWR VPWR sky130_fd_sc_hd__decap_3
X_4782_ _4413_/A _4444_/X _4780_/Y _4969_/B VGND VGND VPWR VPWR _4782_/Y sky130_fd_sc_hd__o31ai_2
XPHY_EDGE_ROW_72_Left_189 VGND VGND VPWR VPWR sky130_fd_sc_hd__decap_3
XFILLER_20_259 VGND VGND VPWR VPWR sky130_fd_sc_hd__fill_1
X_6521_ _6649_/A VGND VGND VPWR VPWR _6521_/Y sky130_fd_sc_hd__inv_2
X_3733_ _3746_/A _3741_/B _3733_/C VGND VGND VPWR VPWR _3733_/X sky130_fd_sc_hd__and3_2
XFILLER_9_260 VGND VGND VPWR VPWR sky130_fd_sc_hd__decap_3
XFILLER_109_29 VGND VGND VPWR VPWR sky130_fd_sc_hd__decap_3
X_6452_ _6610_/A VGND VGND VPWR VPWR _6452_/Y sky130_fd_sc_hd__inv_2
Xclkload30 _7364_/CLK VGND VGND VPWR VPWR clkload30/Y sky130_fd_sc_hd__clkinv_2
X_6383_ _6612_/A VGND VGND VPWR VPWR _6383_/Y sky130_fd_sc_hd__inv_2
X_3595_ _4292_/A _3594_/B _3594_/Y _5020_/A VGND VGND VPWR VPWR _3614_/A sky130_fd_sc_hd__a211o_2
XFILLER_0_609 VGND VGND VPWR VPWR sky130_fd_sc_hd__decap_3
XFILLER_102_504 VGND VGND VPWR VPWR sky130_fd_sc_hd__decap_3
XFILLER_114_386 VGND VGND VPWR VPWR sky130_fd_sc_hd__decap_3
XPHY_EDGE_ROW_81_Left_198 VGND VGND VPWR VPWR sky130_fd_sc_hd__decap_3
XFILLER_102_548 VGND VGND VPWR VPWR sky130_fd_sc_hd__decap_3
XFILLER_87_237 VGND VGND VPWR VPWR sky130_fd_sc_hd__decap_3
X_7004_ _7374_/CLK _7004_/D _6284_/Y VGND VGND VPWR VPWR _7004_/Q sky130_fd_sc_hd__dfrtp_2
X_5196_ _5196_/A _5209_/B VGND VGND VPWR VPWR _7230_/D sky130_fd_sc_hd__and2_2
X_4216_ _7068_/Q _4265_/B _4205_/A VGND VGND VPWR VPWR _4371_/B sky130_fd_sc_hd__o21a_2
XFILLER_28_315 VGND VGND VPWR VPWR sky130_fd_sc_hd__fill_1
XFILLER_56_613 VGND VGND VPWR VPWR sky130_fd_sc_hd__decap_3
X_4147_ _7266_/Q _4422_/A2 _3958_/S _7330_/Q _4146_/X VGND VGND VPWR VPWR _4147_/X
+ sky130_fd_sc_hd__a221o_2
XFILLER_110_581 VGND VGND VPWR VPWR sky130_fd_sc_hd__decap_3
XFILLER_110_592 VGND VGND VPWR VPWR sky130_fd_sc_hd__decap_3
XFILLER_28_326 VGND VGND VPWR VPWR sky130_fd_sc_hd__decap_3
XFILLER_56_657 VGND VGND VPWR VPWR sky130_fd_sc_hd__decap_3
XFILLER_95_281 VGND VGND VPWR VPWR sky130_fd_sc_hd__fill_2
XFILLER_95_292 VGND VGND VPWR VPWR sky130_fd_sc_hd__decap_3
X_4078_ _7025_/Q _4437_/A2 _4394_/B _7371_/Q VGND VGND VPWR VPWR _4078_/X sky130_fd_sc_hd__a22o_2
XFILLER_43_329 VGND VGND VPWR VPWR sky130_fd_sc_hd__decap_3
XFILLER_64_690 VGND VGND VPWR VPWR sky130_fd_sc_hd__fill_1
XFILLER_71_638 VGND VGND VPWR VPWR sky130_fd_sc_hd__decap_3
XFILLER_24_554 VGND VGND VPWR VPWR sky130_fd_sc_hd__decap_3
XFILLER_34_25 VGND VGND VPWR VPWR sky130_fd_sc_hd__decap_3
XFILLER_70_148 VGND VGND VPWR VPWR sky130_fd_sc_hd__decap_3
XFILLER_24_587 VGND VGND VPWR VPWR sky130_fd_sc_hd__fill_1
XFILLER_24_598 VGND VGND VPWR VPWR sky130_fd_sc_hd__decap_3
XFILLER_7_208 VGND VGND VPWR VPWR sky130_fd_sc_hd__decap_3
Xclkload2 clkload2/A VGND VGND VPWR VPWR clkload2/X sky130_fd_sc_hd__clkbuf_16
X_6719_ _6974_/CLK _6719_/D VGND VGND VPWR VPWR _6719_/Q sky130_fd_sc_hd__dfxtp_2
XFILLER_109_136 VGND VGND VPWR VPWR sky130_fd_sc_hd__fill_2
XFILLER_109_169 VGND VGND VPWR VPWR sky130_fd_sc_hd__decap_3
XFILLER_50_79 VGND VGND VPWR VPWR sky130_fd_sc_hd__decap_3
XFILLER_3_469 VGND VGND VPWR VPWR sky130_fd_sc_hd__decap_3
XFILLER_59_55 VGND VGND VPWR VPWR sky130_fd_sc_hd__fill_1
XFILLER_59_66 VGND VGND VPWR VPWR sky130_fd_sc_hd__decap_3
XFILLER_78_215 VGND VGND VPWR VPWR sky130_fd_sc_hd__decap_3
XFILLER_78_248 VGND VGND VPWR VPWR sky130_fd_sc_hd__decap_3
XFILLER_78_259 VGND VGND VPWR VPWR sky130_fd_sc_hd__decap_3
XFILLER_115_72 VGND VGND VPWR VPWR sky130_fd_sc_hd__decap_3
XFILLER_101_570 VGND VGND VPWR VPWR sky130_fd_sc_hd__decap_3
XFILLER_19_337 VGND VGND VPWR VPWR sky130_fd_sc_hd__decap_3
XFILLER_47_635 VGND VGND VPWR VPWR sky130_fd_sc_hd__decap_3
XFILLER_59_484 VGND VGND VPWR VPWR sky130_fd_sc_hd__decap_3
XFILLER_74_410 VGND VGND VPWR VPWR sky130_fd_sc_hd__decap_3
XFILLER_74_432 VGND VGND VPWR VPWR sky130_fd_sc_hd__decap_3
XFILLER_75_43 VGND VGND VPWR VPWR sky130_fd_sc_hd__decap_3
XTAP_TAPCELL_ROW_70_1094 VGND VPWR sky130_fd_sc_hd__tapvpwrvgnd_1
XFILLER_19_359 VGND VGND VPWR VPWR sky130_fd_sc_hd__decap_3
XFILLER_47_668 VGND VGND VPWR VPWR sky130_fd_sc_hd__decap_3
XFILLER_47_679 VGND VGND VPWR VPWR sky130_fd_sc_hd__decap_3
XFILLER_62_616 VGND VGND VPWR VPWR sky130_fd_sc_hd__decap_3
XFILLER_75_76 VGND VGND VPWR VPWR sky130_fd_sc_hd__decap_3
XTAP_TAPCELL_ROW_109_1558 VGND VPWR sky130_fd_sc_hd__tapvpwrvgnd_1
XFILLER_27_370 VGND VGND VPWR VPWR sky130_fd_sc_hd__decap_3
XFILLER_15_532 VGND VGND VPWR VPWR sky130_fd_sc_hd__decap_3
XFILLER_42_340 VGND VGND VPWR VPWR sky130_fd_sc_hd__decap_3
XFILLER_15_576 VGND VGND VPWR VPWR sky130_fd_sc_hd__decap_3
XFILLER_70_660 VGND VGND VPWR VPWR sky130_fd_sc_hd__decap_3
XFILLER_91_53 VGND VGND VPWR VPWR sky130_fd_sc_hd__decap_3
XFILLER_98_9 VGND VGND VPWR VPWR sky130_fd_sc_hd__decap_3
XTAP_TAPCELL_ROW_53_891 VGND VPWR sky130_fd_sc_hd__tapvpwrvgnd_1
XFILLER_24_91 VGND VGND VPWR VPWR sky130_fd_sc_hd__decap_3
XFILLER_30_579 VGND VGND VPWR VPWR sky130_fd_sc_hd__decap_3
Xhold709 _6863_/Q VGND VGND VPWR VPWR _6863_/D sky130_fd_sc_hd__dlygate4sd3_1
XFILLER_115_128 VGND VGND VPWR VPWR sky130_fd_sc_hd__decap_3
X_3380_ _3528_/A _5118_/D VGND VGND VPWR VPWR _3380_/Y sky130_fd_sc_hd__nor2_2
XFILLER_97_535 VGND VGND VPWR VPWR sky130_fd_sc_hd__decap_3
XFILLER_2_480 VGND VGND VPWR VPWR sky130_fd_sc_hd__decap_3
XFILLER_69_237 VGND VGND VPWR VPWR sky130_fd_sc_hd__decap_3
XFILLER_69_248 VGND VGND VPWR VPWR sky130_fd_sc_hd__decap_3
X_5050_ _5086_/A _5101_/B _5100_/B _4366_/X VGND VGND VPWR VPWR _5050_/X sky130_fd_sc_hd__a31o_2
XFILLER_38_613 VGND VGND VPWR VPWR sky130_fd_sc_hd__decap_3
XFILLER_84_207 VGND VGND VPWR VPWR sky130_fd_sc_hd__decap_3
XFILLER_97_579 VGND VGND VPWR VPWR sky130_fd_sc_hd__decap_3
XFILLER_77_281 VGND VGND VPWR VPWR sky130_fd_sc_hd__decap_3
XTAP_TAPCELL_ROW_88_1311 VGND VPWR sky130_fd_sc_hd__tapvpwrvgnd_1
XFILLER_38_657 VGND VGND VPWR VPWR sky130_fd_sc_hd__decap_3
XFILLER_37_167 VGND VGND VPWR VPWR sky130_fd_sc_hd__fill_1
XFILLER_37_178 VGND VGND VPWR VPWR sky130_fd_sc_hd__fill_2
XFILLER_37_189 VGND VGND VPWR VPWR sky130_fd_sc_hd__decap_3
XFILLER_52_104 VGND VGND VPWR VPWR sky130_fd_sc_hd__decap_3
XFILLER_53_638 VGND VGND VPWR VPWR sky130_fd_sc_hd__decap_3
XFILLER_65_476 VGND VGND VPWR VPWR sky130_fd_sc_hd__decap_3
XFILLER_65_498 VGND VGND VPWR VPWR sky130_fd_sc_hd__decap_3
XFILLER_80_402 VGND VGND VPWR VPWR sky130_fd_sc_hd__decap_3
XFILLER_46_690 VGND VGND VPWR VPWR sky130_fd_sc_hd__fill_1
XFILLER_80_435 VGND VGND VPWR VPWR sky130_fd_sc_hd__fill_2
X_4903_ _4903_/A _4903_/B _4903_/C VGND VGND VPWR VPWR _4903_/X sky130_fd_sc_hd__and3_2
XFILLER_33_351 VGND VGND VPWR VPWR sky130_fd_sc_hd__decap_3
XFILLER_61_671 VGND VGND VPWR VPWR sky130_fd_sc_hd__fill_1
XFILLER_61_682 VGND VGND VPWR VPWR sky130_fd_sc_hd__decap_3
XFILLER_21_535 VGND VGND VPWR VPWR sky130_fd_sc_hd__decap_3
X_4834_ _4834_/A _4834_/B VGND VGND VPWR VPWR _4834_/Y sky130_fd_sc_hd__nor2_2
XFILLER_21_579 VGND VGND VPWR VPWR sky130_fd_sc_hd__decap_3
X_4765_ _4788_/A _4765_/B VGND VGND VPWR VPWR _4766_/A sky130_fd_sc_hd__and2_2
X_6504_ _6635_/A VGND VGND VPWR VPWR _6504_/Y sky130_fd_sc_hd__inv_2
XTAP_TAPCELL_ROW_99_1440 VGND VPWR sky130_fd_sc_hd__tapvpwrvgnd_1
XFILLER_107_629 VGND VGND VPWR VPWR sky130_fd_sc_hd__decap_3
X_4696_ _5118_/C _4696_/B VGND VGND VPWR VPWR _5670_/B sky130_fd_sc_hd__nor2_2
XFILLER_106_117 VGND VGND VPWR VPWR sky130_fd_sc_hd__decap_3
XFILLER_106_139 VGND VGND VPWR VPWR sky130_fd_sc_hd__fill_1
X_6435_ _6596_/A VGND VGND VPWR VPWR _6435_/Y sky130_fd_sc_hd__inv_2
XFILLER_115_662 VGND VGND VPWR VPWR sky130_fd_sc_hd__decap_3
X_6366_ _6683_/A VGND VGND VPWR VPWR _6366_/Y sky130_fd_sc_hd__inv_2
X_3578_ _7284_/Q _5159_/S _3417_/X _7092_/Q VGND VGND VPWR VPWR _3583_/A sky130_fd_sc_hd__a22o_2
XFILLER_0_428 VGND VGND VPWR VPWR sky130_fd_sc_hd__decap_3
XFILLER_114_150 VGND VGND VPWR VPWR sky130_fd_sc_hd__decap_3
XFILLER_114_172 VGND VGND VPWR VPWR sky130_fd_sc_hd__decap_3
XFILLER_115_673 VGND VGND VPWR VPWR sky130_fd_sc_hd__decap_3
X_5317_ _5317_/A0 _4899_/X _5340_/S VGND VGND VPWR VPWR _7172_/D sky130_fd_sc_hd__mux2_2
XFILLER_102_323 VGND VGND VPWR VPWR sky130_fd_sc_hd__decap_3
XFILLER_88_557 VGND VGND VPWR VPWR sky130_fd_sc_hd__decap_3
X_6297_ _6581_/A VGND VGND VPWR VPWR _6297_/Y sky130_fd_sc_hd__inv_2
XFILLER_102_389 VGND VGND VPWR VPWR sky130_fd_sc_hd__decap_3
XFILLER_29_635 VGND VGND VPWR VPWR sky130_fd_sc_hd__decap_3
XFILLER_56_410 VGND VGND VPWR VPWR sky130_fd_sc_hd__decap_3
XFILLER_56_421 VGND VGND VPWR VPWR sky130_fd_sc_hd__decap_3
XFILLER_68_292 VGND VGND VPWR VPWR sky130_fd_sc_hd__decap_3
X_5179_ _5179_/A _5190_/B VGND VGND VPWR VPWR _7238_/D sky130_fd_sc_hd__and2_2
XFILLER_28_156 VGND VGND VPWR VPWR sky130_fd_sc_hd__decap_3
XFILLER_29_668 VGND VGND VPWR VPWR sky130_fd_sc_hd__decap_3
XFILLER_29_679 VGND VGND VPWR VPWR sky130_fd_sc_hd__decap_3
XFILLER_56_465 VGND VGND VPWR VPWR sky130_fd_sc_hd__decap_3
XFILLER_28_189 VGND VGND VPWR VPWR sky130_fd_sc_hd__decap_3
XFILLER_44_616 VGND VGND VPWR VPWR sky130_fd_sc_hd__decap_3
XFILLER_83_284 VGND VGND VPWR VPWR sky130_fd_sc_hd__decap_3
XTAP_TAPCELL_ROW_3_288 VGND VPWR sky130_fd_sc_hd__tapvpwrvgnd_1
XFILLER_45_57 VGND VGND VPWR VPWR sky130_fd_sc_hd__fill_1
XFILLER_24_362 VGND VGND VPWR VPWR sky130_fd_sc_hd__fill_2
XFILLER_52_660 VGND VGND VPWR VPWR sky130_fd_sc_hd__decap_3
XFILLER_71_479 VGND VGND VPWR VPWR sky130_fd_sc_hd__fill_1
XFILLER_51_181 VGND VGND VPWR VPWR sky130_fd_sc_hd__decap_3
XFILLER_61_12 VGND VGND VPWR VPWR sky130_fd_sc_hd__decap_3
XTAP_TAPCELL_ROW_104_1499 VGND VPWR sky130_fd_sc_hd__tapvpwrvgnd_1
XFILLER_12_557 VGND VGND VPWR VPWR sky130_fd_sc_hd__decap_3
XFILLER_8_528 VGND VGND VPWR VPWR sky130_fd_sc_hd__decap_3
XTAP_TAPCELL_ROW_50_850 VGND VPWR sky130_fd_sc_hd__tapvpwrvgnd_1
XFILLER_8_539 VGND VGND VPWR VPWR sky130_fd_sc_hd__decap_3
XFILLER_6_29 VGND VGND VPWR VPWR sky130_fd_sc_hd__fill_2
XFILLER_3_211 VGND VGND VPWR VPWR sky130_fd_sc_hd__decap_3
XFILLER_106_640 VGND VGND VPWR VPWR sky130_fd_sc_hd__decap_3
XFILLER_106_651 VGND VGND VPWR VPWR sky130_fd_sc_hd__decap_3
XFILLER_3_233 VGND VGND VPWR VPWR sky130_fd_sc_hd__decap_3
XFILLER_106_684 VGND VGND VPWR VPWR sky130_fd_sc_hd__decap_3
XFILLER_10_82 VGND VGND VPWR VPWR sky130_fd_sc_hd__fill_2
XTAP_TAPCELL_ROW_72_1112 VGND VPWR sky130_fd_sc_hd__tapvpwrvgnd_1
XFILLER_105_172 VGND VGND VPWR VPWR sky130_fd_sc_hd__decap_3
XFILLER_79_557 VGND VGND VPWR VPWR sky130_fd_sc_hd__decap_3
XFILLER_79_579 VGND VGND VPWR VPWR sky130_fd_sc_hd__decap_3
XFILLER_19_101 VGND VGND VPWR VPWR sky130_fd_sc_hd__decap_3
XFILLER_59_281 VGND VGND VPWR VPWR sky130_fd_sc_hd__decap_3
XFILLER_19_80 VGND VGND VPWR VPWR sky130_fd_sc_hd__decap_3
XTAP_TAPCELL_ROW_58_950 VGND VPWR sky130_fd_sc_hd__tapvpwrvgnd_1
XFILLER_19_167 VGND VGND VPWR VPWR sky130_fd_sc_hd__fill_1
XFILLER_19_189 VGND VGND VPWR VPWR sky130_fd_sc_hd__decap_3
XFILLER_35_638 VGND VGND VPWR VPWR sky130_fd_sc_hd__decap_3
XFILLER_74_262 VGND VGND VPWR VPWR sky130_fd_sc_hd__decap_3
XFILLER_28_690 VGND VGND VPWR VPWR sky130_fd_sc_hd__fill_1
XFILLER_43_671 VGND VGND VPWR VPWR sky130_fd_sc_hd__fill_1
XFILLER_50_619 VGND VGND VPWR VPWR sky130_fd_sc_hd__decap_3
XTAP_TAPCELL_ROW_83_1252 VGND VPWR sky130_fd_sc_hd__tapvpwrvgnd_1
XFILLER_35_90 VGND VGND VPWR VPWR sky130_fd_sc_hd__decap_3
XFILLER_43_682 VGND VGND VPWR VPWR sky130_fd_sc_hd__decap_3
XFILLER_96_6 VGND VGND VPWR VPWR sky130_fd_sc_hd__decap_3
XFILLER_30_365 VGND VGND VPWR VPWR sky130_fd_sc_hd__decap_3
XFILLER_7_550 VGND VGND VPWR VPWR sky130_fd_sc_hd__decap_3
X_4550_ _4550_/A _4563_/B VGND VGND VPWR VPWR _7305_/D sky130_fd_sc_hd__and2_2
XFILLER_7_561 VGND VGND VPWR VPWR sky130_fd_sc_hd__decap_3
XFILLER_7_594 VGND VGND VPWR VPWR sky130_fd_sc_hd__decap_3
X_3501_ _5144_/A _5144_/B _3500_/Y VGND VGND VPWR VPWR _3501_/X sky130_fd_sc_hd__a21o_2
XFILLER_112_610 VGND VGND VPWR VPWR sky130_fd_sc_hd__decap_3
X_3363_ _3561_/A _6983_/Q _5129_/B VGND VGND VPWR VPWR _5294_/B sky130_fd_sc_hd__or3b_4
XTAP_TAPCELL_ROW_94_1381 VGND VPWR sky130_fd_sc_hd__tapvpwrvgnd_1
XFILLER_112_643 VGND VGND VPWR VPWR sky130_fd_sc_hd__fill_1
XFILLER_112_654 VGND VGND VPWR VPWR sky130_fd_sc_hd__decap_3
XFILLER_97_343 VGND VGND VPWR VPWR sky130_fd_sc_hd__decap_3
X_5102_ _5114_/A _4343_/X _5100_/Y _3618_/X _5101_/Y VGND VGND VPWR VPWR _5102_/X
+ sky130_fd_sc_hd__a221o_2
XFILLER_112_687 VGND VGND VPWR VPWR sky130_fd_sc_hd__decap_3
XFILLER_85_505 VGND VGND VPWR VPWR sky130_fd_sc_hd__decap_3
Xhold1206 _7380_/Q VGND VGND VPWR VPWR _3905_/A1 sky130_fd_sc_hd__dlygate4sd3_1
XFILLER_38_421 VGND VGND VPWR VPWR sky130_fd_sc_hd__decap_3
XFILLER_85_527 VGND VGND VPWR VPWR sky130_fd_sc_hd__decap_3
Xhold1217 _7377_/Q VGND VGND VPWR VPWR _3920_/A1 sky130_fd_sc_hd__dlygate4sd3_1
Xhold1228 _7306_/Q VGND VGND VPWR VPWR _4482_/A1 sky130_fd_sc_hd__dlygate4sd3_1
X_5033_ _5114_/A _4629_/Y _5032_/A _5033_/B2 VGND VGND VPWR VPWR _5033_/X sky130_fd_sc_hd__a22o_2
XFILLER_38_454 VGND VGND VPWR VPWR sky130_fd_sc_hd__decap_3
XFILLER_26_616 VGND VGND VPWR VPWR sky130_fd_sc_hd__decap_3
XFILLER_65_273 VGND VGND VPWR VPWR sky130_fd_sc_hd__decap_3
XFILLER_65_284 VGND VGND VPWR VPWR sky130_fd_sc_hd__decap_3
XFILLER_93_582 VGND VGND VPWR VPWR sky130_fd_sc_hd__decap_3
XTAP_TAPCELL_ROW_0_236 VGND VPWR sky130_fd_sc_hd__tapvpwrvgnd_1
XFILLER_25_126 VGND VGND VPWR VPWR sky130_fd_sc_hd__decap_3
X_6984_ _7383_/CLK _6984_/D _6264_/Y VGND VGND VPWR VPWR _6984_/Q sky130_fd_sc_hd__dfrtp_2
XTAP_TAPCELL_ROW_0_247 VGND VPWR sky130_fd_sc_hd__tapvpwrvgnd_1
XFILLER_15_38 VGND VGND VPWR VPWR sky130_fd_sc_hd__fill_1
XFILLER_25_159 VGND VGND VPWR VPWR sky130_fd_sc_hd__decap_3
XFILLER_34_660 VGND VGND VPWR VPWR sky130_fd_sc_hd__decap_3
XFILLER_53_479 VGND VGND VPWR VPWR sky130_fd_sc_hd__decap_3
XFILLER_40_129 VGND VGND VPWR VPWR sky130_fd_sc_hd__decap_3
XTAP_TAPCELL_ROW_36_688 VGND VPWR sky130_fd_sc_hd__tapvpwrvgnd_1
XFILLER_21_354 VGND VGND VPWR VPWR sky130_fd_sc_hd__fill_1
X_4817_ _4810_/X _4811_/X _4815_/X _4816_/X VGND VGND VPWR VPWR _5663_/B sky130_fd_sc_hd__a211o_2
X_4748_ _3683_/Y _5664_/B _4791_/C1 VGND VGND VPWR VPWR _4751_/A sky130_fd_sc_hd__a21o_2
X_4679_ _6990_/Q _5014_/B VGND VGND VPWR VPWR _5015_/B sky130_fd_sc_hd__nand2_2
X_6418_ _6610_/A VGND VGND VPWR VPWR _6418_/Y sky130_fd_sc_hd__inv_2
XPHY_EDGE_ROW_1_Right_1 VGND VGND VPWR VPWR sky130_fd_sc_hd__decap_3
XFILLER_0_203 VGND VGND VPWR VPWR sky130_fd_sc_hd__fill_2
XFILLER_115_470 VGND VGND VPWR VPWR sky130_fd_sc_hd__decap_3
X_7398_ _7398_/CLK _7398_/D _6678_/Y VGND VGND VPWR VPWR _7398_/Q sky130_fd_sc_hd__dfrtp_2
XFILLER_0_225 VGND VGND VPWR VPWR sky130_fd_sc_hd__fill_2
XFILLER_103_632 VGND VGND VPWR VPWR sky130_fd_sc_hd__decap_3
X_6349_ _6663_/A VGND VGND VPWR VPWR _6349_/Y sky130_fd_sc_hd__inv_2
XTAP_TAPCELL_ROW_8_347 VGND VPWR sky130_fd_sc_hd__tapvpwrvgnd_1
XFILLER_0_247 VGND VGND VPWR VPWR sky130_fd_sc_hd__decap_3
XFILLER_103_665 VGND VGND VPWR VPWR sky130_fd_sc_hd__decap_3
XFILLER_103_676 VGND VGND VPWR VPWR sky130_fd_sc_hd__decap_3
XFILLER_88_354 VGND VGND VPWR VPWR sky130_fd_sc_hd__fill_1
XFILLER_88_365 VGND VGND VPWR VPWR sky130_fd_sc_hd__decap_3
XFILLER_29_410 VGND VGND VPWR VPWR sky130_fd_sc_hd__decap_3
XFILLER_56_12 VGND VGND VPWR VPWR sky130_fd_sc_hd__decap_3
XFILLER_91_508 VGND VGND VPWR VPWR sky130_fd_sc_hd__decap_3
XFILLER_17_638 VGND VGND VPWR VPWR sky130_fd_sc_hd__decap_3
XFILLER_44_402 VGND VGND VPWR VPWR sky130_fd_sc_hd__decap_3
XFILLER_56_251 VGND VGND VPWR VPWR sky130_fd_sc_hd__fill_1
XFILLER_56_262 VGND VGND VPWR VPWR sky130_fd_sc_hd__decap_3
XFILLER_84_560 VGND VGND VPWR VPWR sky130_fd_sc_hd__decap_3
XTAP_TAPCELL_ROW_106_1528 VGND VPWR sky130_fd_sc_hd__tapvpwrvgnd_1
XFILLER_112_62 VGND VGND VPWR VPWR sky130_fd_sc_hd__decap_3
XFILLER_16_159 VGND VGND VPWR VPWR sky130_fd_sc_hd__fill_1
XFILLER_25_671 VGND VGND VPWR VPWR sky130_fd_sc_hd__fill_1
XFILLER_31_107 VGND VGND VPWR VPWR sky130_fd_sc_hd__decap_3
XFILLER_32_619 VGND VGND VPWR VPWR sky130_fd_sc_hd__decap_3
XFILLER_71_243 VGND VGND VPWR VPWR sky130_fd_sc_hd__decap_3
XFILLER_12_321 VGND VGND VPWR VPWR sky130_fd_sc_hd__decap_3
XFILLER_25_682 VGND VGND VPWR VPWR sky130_fd_sc_hd__decap_3
XFILLER_71_287 VGND VGND VPWR VPWR sky130_fd_sc_hd__decap_3
XFILLER_72_77 VGND VGND VPWR VPWR sky130_fd_sc_hd__decap_3
XFILLER_40_663 VGND VGND VPWR VPWR sky130_fd_sc_hd__decap_3
XFILLER_12_387 VGND VGND VPWR VPWR sky130_fd_sc_hd__decap_3
XFILLER_4_531 VGND VGND VPWR VPWR sky130_fd_sc_hd__fill_1
XFILLER_4_542 VGND VGND VPWR VPWR sky130_fd_sc_hd__decap_3
XFILLER_113_429 VGND VGND VPWR VPWR sky130_fd_sc_hd__decap_3
XFILLER_21_92 VGND VGND VPWR VPWR sky130_fd_sc_hd__fill_1
XFILLER_4_575 VGND VGND VPWR VPWR sky130_fd_sc_hd__decap_3
XFILLER_98_118 VGND VGND VPWR VPWR sky130_fd_sc_hd__decap_3
XFILLER_106_492 VGND VGND VPWR VPWR sky130_fd_sc_hd__decap_3
XFILLER_79_332 VGND VGND VPWR VPWR sky130_fd_sc_hd__decap_3
XFILLER_79_343 VGND VGND VPWR VPWR sky130_fd_sc_hd__decap_3
XFILLER_94_302 VGND VGND VPWR VPWR sky130_fd_sc_hd__decap_3
XFILLER_79_387 VGND VGND VPWR VPWR sky130_fd_sc_hd__decap_3
XFILLER_47_251 VGND VGND VPWR VPWR sky130_fd_sc_hd__decap_3
XFILLER_75_582 VGND VGND VPWR VPWR sky130_fd_sc_hd__decap_3
XFILLER_35_435 VGND VGND VPWR VPWR sky130_fd_sc_hd__decap_3
XFILLER_47_284 VGND VGND VPWR VPWR sky130_fd_sc_hd__decap_3
XFILLER_62_221 VGND VGND VPWR VPWR sky130_fd_sc_hd__decap_3
XFILLER_62_232 VGND VGND VPWR VPWR sky130_fd_sc_hd__decap_3
XFILLER_16_660 VGND VGND VPWR VPWR sky130_fd_sc_hd__decap_3
XFILLER_50_416 VGND VGND VPWR VPWR sky130_fd_sc_hd__decap_3
XFILLER_90_563 VGND VGND VPWR VPWR sky130_fd_sc_hd__decap_3
X_3981_ _7350_/Q _4522_/A0 _3987_/S VGND VGND VPWR VPWR _7350_/D sky130_fd_sc_hd__mux2_2
XFILLER_50_427 VGND VGND VPWR VPWR sky130_fd_sc_hd__decap_3
XFILLER_62_287 VGND VGND VPWR VPWR sky130_fd_sc_hd__decap_3
XFILLER_31_641 VGND VGND VPWR VPWR sky130_fd_sc_hd__decap_3
XFILLER_94_3 VGND VGND VPWR VPWR sky130_fd_sc_hd__decap_3
XTAP_TAPCELL_ROW_61_978 VGND VPWR sky130_fd_sc_hd__tapvpwrvgnd_1
XTAP_TAPCELL_ROW_33_647 VGND VPWR sky130_fd_sc_hd__tapvpwrvgnd_1
XFILLER_31_685 VGND VGND VPWR VPWR sky130_fd_sc_hd__decap_3
X_5651_ _5660_/C VGND VGND VPWR VPWR _5651_/Y sky130_fd_sc_hd__inv_2
XTAP_TAPCELL_ROW_61_989 VGND VPWR sky130_fd_sc_hd__tapvpwrvgnd_1
X_7321_ _7322_/CLK _7321_/D _6601_/Y VGND VGND VPWR VPWR _7321_/Q sky130_fd_sc_hd__dfrtp_2
XFILLER_7_94 VGND VGND VPWR VPWR sky130_fd_sc_hd__fill_2
X_7252_ _7349_/CLK _7252_/D _6532_/Y VGND VGND VPWR VPWR _7252_/Q sky130_fd_sc_hd__dfrtp_2
X_4464_ _3541_/X _3610_/B _4463_/X VGND VGND VPWR VPWR _5655_/C sky130_fd_sc_hd__o21ai_2
X_7183_ clkload7/A _7183_/D _6463_/Y VGND VGND VPWR VPWR _7183_/Q sky130_fd_sc_hd__dfrtp_2
X_4395_ _4396_/A _4444_/B VGND VGND VPWR VPWR _4397_/A sky130_fd_sc_hd__and2_2
X_3415_ _3449_/B _3449_/C _3417_/C VGND VGND VPWR VPWR _5159_/S sky130_fd_sc_hd__and3_4
XFILLER_112_451 VGND VGND VPWR VPWR sky130_fd_sc_hd__decap_3
X_3346_ _3346_/A VGND VGND VPWR VPWR _3509_/B sky130_fd_sc_hd__inv_2
XTAP_TAPCELL_ROW_5_317 VGND VPWR sky130_fd_sc_hd__tapvpwrvgnd_1
XTAP_TAPCELL_ROW_5_306 VGND VPWR sky130_fd_sc_hd__tapvpwrvgnd_1
XFILLER_98_663 VGND VGND VPWR VPWR sky130_fd_sc_hd__decap_3
XFILLER_100_613 VGND VGND VPWR VPWR sky130_fd_sc_hd__decap_3
XFILLER_112_495 VGND VGND VPWR VPWR sky130_fd_sc_hd__decap_3
XFILLER_85_324 VGND VGND VPWR VPWR sky130_fd_sc_hd__decap_3
XFILLER_85_335 VGND VGND VPWR VPWR sky130_fd_sc_hd__fill_1
XFILLER_97_162 VGND VGND VPWR VPWR sky130_fd_sc_hd__decap_3
XFILLER_97_184 VGND VGND VPWR VPWR sky130_fd_sc_hd__decap_3
Xhold1003 _7192_/Q VGND VGND VPWR VPWR _5276_/A0 sky130_fd_sc_hd__dlygate4sd3_1
Xhold1014 _7273_/Q VGND VGND VPWR VPWR _4807_/A0 sky130_fd_sc_hd__dlygate4sd3_1
XFILLER_100_657 VGND VGND VPWR VPWR sky130_fd_sc_hd__decap_3
Xhold1025 _7040_/Q VGND VGND VPWR VPWR _5577_/A0 sky130_fd_sc_hd__dlygate4sd3_1
Xhold1036 _7245_/Q VGND VGND VPWR VPWR _5165_/A sky130_fd_sc_hd__dlygate4sd3_1
Xhold1047 _7247_/Q VGND VGND VPWR VPWR _5159_/A0 sky130_fd_sc_hd__dlygate4sd3_1
Xhold1058 _7251_/Q VGND VGND VPWR VPWR _5136_/A0 sky130_fd_sc_hd__dlygate4sd3_1
X_5016_ _5032_/A _5031_/B _4629_/Y VGND VGND VPWR VPWR _5017_/B sky130_fd_sc_hd__a21oi_2
XFILLER_38_273 VGND VGND VPWR VPWR sky130_fd_sc_hd__decap_3
XFILLER_66_560 VGND VGND VPWR VPWR sky130_fd_sc_hd__decap_3
Xhold1069 _7300_/Q VGND VGND VPWR VPWR _4561_/A sky130_fd_sc_hd__dlygate4sd3_1
XFILLER_26_26 VGND VGND VPWR VPWR sky130_fd_sc_hd__fill_2
XFILLER_81_530 VGND VGND VPWR VPWR sky130_fd_sc_hd__decap_3
XFILLER_14_619 VGND VGND VPWR VPWR sky130_fd_sc_hd__decap_3
XFILLER_26_457 VGND VGND VPWR VPWR sky130_fd_sc_hd__decap_3
XFILLER_41_405 VGND VGND VPWR VPWR sky130_fd_sc_hd__decap_3
X_6967_ _6970_/CLK _6967_/D VGND VGND VPWR VPWR _6967_/Q sky130_fd_sc_hd__dfxtp_2
XFILLER_41_438 VGND VGND VPWR VPWR sky130_fd_sc_hd__fill_1
XFILLER_41_449 VGND VGND VPWR VPWR sky130_fd_sc_hd__fill_1
XFILLER_53_276 VGND VGND VPWR VPWR sky130_fd_sc_hd__decap_3
XFILLER_53_287 VGND VGND VPWR VPWR sky130_fd_sc_hd__decap_3
XFILLER_81_585 VGND VGND VPWR VPWR sky130_fd_sc_hd__decap_3
Xclkbuf_leaf_33_clk clkload1/A VGND VGND VPWR VPWR _7350_/CLK sky130_fd_sc_hd__clkbuf_16
X_6898_ _6978_/CLK _6898_/D VGND VGND VPWR VPWR _6898_/Q sky130_fd_sc_hd__dfxtp_2
XFILLER_21_162 VGND VGND VPWR VPWR sky130_fd_sc_hd__decap_3
XFILLER_22_663 VGND VGND VPWR VPWR sky130_fd_sc_hd__decap_3
XTAP_TAPCELL_ROW_101_1469 VGND VPWR sky130_fd_sc_hd__tapvpwrvgnd_1
XTAP_TAPCELL_ROW_101_1458 VGND VPWR sky130_fd_sc_hd__tapvpwrvgnd_1
XFILLER_107_201 VGND VGND VPWR VPWR sky130_fd_sc_hd__decap_3
XFILLER_5_317 VGND VGND VPWR VPWR sky130_fd_sc_hd__fill_1
XFILLER_107_267 VGND VGND VPWR VPWR sky130_fd_sc_hd__decap_3
XFILLER_1_523 VGND VGND VPWR VPWR sky130_fd_sc_hd__decap_3
XFILLER_89_641 VGND VGND VPWR VPWR sky130_fd_sc_hd__decap_3
Xhold870 _7112_/Q VGND VGND VPWR VPWR _7112_/D sky130_fd_sc_hd__dlygate4sd3_1
Xhold881 _7078_/Q VGND VGND VPWR VPWR _7078_/D sky130_fd_sc_hd__dlygate4sd3_1
XFILLER_107_51 VGND VGND VPWR VPWR sky130_fd_sc_hd__decap_3
XFILLER_107_73 VGND VGND VPWR VPWR sky130_fd_sc_hd__decap_3
XFILLER_1_556 VGND VGND VPWR VPWR sky130_fd_sc_hd__decap_3
XFILLER_1_567 VGND VGND VPWR VPWR sky130_fd_sc_hd__decap_3
XFILLER_67_11 VGND VGND VPWR VPWR sky130_fd_sc_hd__decap_3
Xhold892 _7079_/Q VGND VGND VPWR VPWR _7079_/D sky130_fd_sc_hd__dlygate4sd3_1
XFILLER_103_462 VGND VGND VPWR VPWR sky130_fd_sc_hd__decap_3
XFILLER_103_495 VGND VGND VPWR VPWR sky130_fd_sc_hd__decap_3
XFILLER_1_589 VGND VGND VPWR VPWR sky130_fd_sc_hd__decap_3
XFILLER_49_527 VGND VGND VPWR VPWR sky130_fd_sc_hd__fill_2
XFILLER_67_55 VGND VGND VPWR VPWR sky130_fd_sc_hd__fill_1
XFILLER_89_685 VGND VGND VPWR VPWR sky130_fd_sc_hd__decap_3
XTAP_TAPCELL_ROW_112_1598 VGND VPWR sky130_fd_sc_hd__tapvpwrvgnd_1
XFILLER_67_99 VGND VGND VPWR VPWR sky130_fd_sc_hd__decap_3
XFILLER_76_357 VGND VGND VPWR VPWR sky130_fd_sc_hd__decap_3
XFILLER_88_195 VGND VGND VPWR VPWR sky130_fd_sc_hd__fill_1
XFILLER_17_402 VGND VGND VPWR VPWR sky130_fd_sc_hd__decap_3
XFILLER_29_240 VGND VGND VPWR VPWR sky130_fd_sc_hd__decap_3
XFILLER_57_582 VGND VGND VPWR VPWR sky130_fd_sc_hd__decap_3
XFILLER_29_284 VGND VGND VPWR VPWR sky130_fd_sc_hd__decap_3
XFILLER_72_541 VGND VGND VPWR VPWR sky130_fd_sc_hd__decap_3
XFILLER_44_243 VGND VGND VPWR VPWR sky130_fd_sc_hd__decap_3
XFILLER_44_265 VGND VGND VPWR VPWR sky130_fd_sc_hd__fill_2
XFILLER_72_574 VGND VGND VPWR VPWR sky130_fd_sc_hd__decap_3
XTAP_TAPCELL_ROW_67_1055 VGND VPWR sky130_fd_sc_hd__tapvpwrvgnd_1
XFILLER_44_276 VGND VGND VPWR VPWR sky130_fd_sc_hd__fill_2
XTAP_TAPCELL_ROW_80_1211 VGND VPWR sky130_fd_sc_hd__tapvpwrvgnd_1
XFILLER_13_641 VGND VGND VPWR VPWR sky130_fd_sc_hd__decap_3
Xclkbuf_leaf_24_clk clkload4/A VGND VGND VPWR VPWR _7328_/CLK sky130_fd_sc_hd__clkbuf_16
XFILLER_13_685 VGND VGND VPWR VPWR sky130_fd_sc_hd__decap_3
XTAP_TAPCELL_ROW_30_617 VGND VPWR sky130_fd_sc_hd__tapvpwrvgnd_1
XTAP_TAPCELL_ROW_30_606 VGND VPWR sky130_fd_sc_hd__tapvpwrvgnd_1
XFILLER_9_623 VGND VGND VPWR VPWR sky130_fd_sc_hd__decap_3
XFILLER_9_612 VGND VGND VPWR VPWR sky130_fd_sc_hd__decap_3
XFILLER_9_656 VGND VGND VPWR VPWR sky130_fd_sc_hd__decap_3
XTAP_TAPCELL_ROW_10_374 VGND VPWR sky130_fd_sc_hd__tapvpwrvgnd_1
XFILLER_59_6 VGND VGND VPWR VPWR sky130_fd_sc_hd__decap_3
XTAP_TAPCELL_ROW_78_1184 VGND VPWR sky130_fd_sc_hd__tapvpwrvgnd_1
XFILLER_4_394 VGND VGND VPWR VPWR sky130_fd_sc_hd__decap_3
XTAP_TAPCELL_ROW_91_1340 VGND VPWR sky130_fd_sc_hd__tapvpwrvgnd_1
XFILLER_79_151 VGND VGND VPWR VPWR sky130_fd_sc_hd__decap_3
XFILLER_95_600 VGND VGND VPWR VPWR sky130_fd_sc_hd__decap_3
X_4180_ _7232_/Q _4331_/A2 _4534_/S _7045_/Q VGND VGND VPWR VPWR _4180_/X sky130_fd_sc_hd__a22o_2
XFILLER_67_302 VGND VGND VPWR VPWR sky130_fd_sc_hd__decap_3
XFILLER_67_313 VGND VGND VPWR VPWR sky130_fd_sc_hd__decap_3
XFILLER_79_184 VGND VGND VPWR VPWR sky130_fd_sc_hd__fill_2
XFILLER_94_110 VGND VGND VPWR VPWR sky130_fd_sc_hd__decap_3
XFILLER_67_357 VGND VGND VPWR VPWR sky130_fd_sc_hd__decap_3
XFILLER_94_132 VGND VGND VPWR VPWR sky130_fd_sc_hd__fill_2
XFILLER_95_644 VGND VGND VPWR VPWR sky130_fd_sc_hd__decap_3
XFILLER_82_327 VGND VGND VPWR VPWR sky130_fd_sc_hd__decap_3
XFILLER_95_688 VGND VGND VPWR VPWR sky130_fd_sc_hd__decap_3
XTAP_TAPCELL_ROW_38_706 VGND VPWR sky130_fd_sc_hd__tapvpwrvgnd_1
XFILLER_48_582 VGND VGND VPWR VPWR sky130_fd_sc_hd__decap_3
XFILLER_82_349 VGND VGND VPWR VPWR sky130_fd_sc_hd__decap_3
XFILLER_94_187 VGND VGND VPWR VPWR sky130_fd_sc_hd__decap_3
XFILLER_35_243 VGND VGND VPWR VPWR sky130_fd_sc_hd__fill_1
X_6821_ clkload6/A _6821_/D VGND VGND VPWR VPWR _6821_/Q sky130_fd_sc_hd__dfxtp_2
XFILLER_23_416 VGND VGND VPWR VPWR sky130_fd_sc_hd__decap_3
XFILLER_23_438 VGND VGND VPWR VPWR sky130_fd_sc_hd__fill_1
XFILLER_35_287 VGND VGND VPWR VPWR sky130_fd_sc_hd__fill_2
XFILLER_35_298 VGND VGND VPWR VPWR sky130_fd_sc_hd__decap_3
XFILLER_63_585 VGND VGND VPWR VPWR sky130_fd_sc_hd__decap_3
XTAP_TAPCELL_ROW_18_463 VGND VPWR sky130_fd_sc_hd__tapvpwrvgnd_1
XFILLER_23_449 VGND VGND VPWR VPWR sky130_fd_sc_hd__decap_3
Xclkbuf_leaf_15_clk clkload3/A VGND VGND VPWR VPWR _7372_/CLK sky130_fd_sc_hd__clkbuf_16
X_6752_ _6954_/CLK _6752_/D VGND VGND VPWR VPWR _6752_/Q sky130_fd_sc_hd__dfxtp_2
X_3964_ _7358_/Q _7326_/Q _3964_/S VGND VGND VPWR VPWR _7358_/D sky130_fd_sc_hd__mux2_2
X_6683_ _6683_/A VGND VGND VPWR VPWR _6683_/Y sky130_fd_sc_hd__inv_2
X_5703_ _7357_/Q hold914/X _5703_/S VGND VGND VPWR VPWR _6701_/D sky130_fd_sc_hd__mux2_2
X_3895_ _3629_/A _3887_/X _3889_/X _3741_/X _3894_/X VGND VGND VPWR VPWR _3895_/X
+ sky130_fd_sc_hd__a221o_2
XFILLER_31_482 VGND VGND VPWR VPWR sky130_fd_sc_hd__decap_3
X_5634_ _5634_/A _5634_/B VGND VGND VPWR VPWR _7011_/D sky130_fd_sc_hd__and2_2
X_7304_ _7368_/CLK _7304_/D _6584_/Y VGND VGND VPWR VPWR _7304_/Q sky130_fd_sc_hd__dfrtp_2
XFILLER_2_309 VGND VGND VPWR VPWR sky130_fd_sc_hd__decap_3
X_7235_ _7365_/CLK _7235_/D _6515_/Y VGND VGND VPWR VPWR _7235_/Q sky130_fd_sc_hd__dfrtp_2
X_4447_ _4795_/A _4447_/B VGND VGND VPWR VPWR _4447_/Y sky130_fd_sc_hd__nor2_2
X_7166_ _7364_/CLK _7166_/D _6446_/Y VGND VGND VPWR VPWR _7166_/Q sky130_fd_sc_hd__dfrtp_2
XFILLER_58_302 VGND VGND VPWR VPWR sky130_fd_sc_hd__decap_3
XFILLER_86_622 VGND VGND VPWR VPWR sky130_fd_sc_hd__decap_3
X_4378_ _4243_/Y _4277_/Y _5032_/B _4377_/Y VGND VGND VPWR VPWR _4968_/A sky130_fd_sc_hd__a31o_4
XFILLER_58_335 VGND VGND VPWR VPWR sky130_fd_sc_hd__fill_1
XFILLER_86_666 VGND VGND VPWR VPWR sky130_fd_sc_hd__decap_3
X_7097_ _7322_/CLK _7097_/D _6377_/Y VGND VGND VPWR VPWR _7097_/Q sky130_fd_sc_hd__dfrtp_2
X_3329_ _6982_/Q _3340_/C VGND VGND VPWR VPWR _3329_/Y sky130_fd_sc_hd__nand2_2
XFILLER_37_25 VGND VGND VPWR VPWR sky130_fd_sc_hd__fill_1
XFILLER_73_305 VGND VGND VPWR VPWR sky130_fd_sc_hd__decap_3
XFILLER_100_498 VGND VGND VPWR VPWR sky130_fd_sc_hd__decap_3
XFILLER_39_582 VGND VGND VPWR VPWR sky130_fd_sc_hd__decap_3
XFILLER_73_327 VGND VGND VPWR VPWR sky130_fd_sc_hd__decap_3
XFILLER_73_349 VGND VGND VPWR VPWR sky130_fd_sc_hd__decap_3
XFILLER_54_563 VGND VGND VPWR VPWR sky130_fd_sc_hd__decap_3
XFILLER_14_416 VGND VGND VPWR VPWR sky130_fd_sc_hd__decap_3
XFILLER_14_427 VGND VGND VPWR VPWR sky130_fd_sc_hd__fill_1
XFILLER_26_265 VGND VGND VPWR VPWR sky130_fd_sc_hd__decap_3
XFILLER_26_287 VGND VGND VPWR VPWR sky130_fd_sc_hd__decap_3
XFILLER_81_371 VGND VGND VPWR VPWR sky130_fd_sc_hd__fill_2
XFILLER_41_246 VGND VGND VPWR VPWR sky130_fd_sc_hd__decap_3
XFILLER_41_279 VGND VGND VPWR VPWR sky130_fd_sc_hd__fill_1
XFILLER_10_622 VGND VGND VPWR VPWR sky130_fd_sc_hd__decap_3
XFILLER_22_493 VGND VGND VPWR VPWR sky130_fd_sc_hd__decap_3
XFILLER_108_510 VGND VGND VPWR VPWR sky130_fd_sc_hd__decap_3
XFILLER_10_666 VGND VGND VPWR VPWR sky130_fd_sc_hd__decap_3
XFILLER_6_604 VGND VGND VPWR VPWR sky130_fd_sc_hd__decap_3
XFILLER_5_125 VGND VGND VPWR VPWR sky130_fd_sc_hd__decap_3
XFILLER_6_637 VGND VGND VPWR VPWR sky130_fd_sc_hd__decap_3
XFILLER_6_648 VGND VGND VPWR VPWR sky130_fd_sc_hd__decap_3
XFILLER_108_554 VGND VGND VPWR VPWR sky130_fd_sc_hd__decap_3
XFILLER_108_587 VGND VGND VPWR VPWR sky130_fd_sc_hd__fill_1
XFILLER_5_169 VGND VGND VPWR VPWR sky130_fd_sc_hd__fill_1
XTAP_TAPCELL_ROW_114_1616 VGND VPWR sky130_fd_sc_hd__tapvpwrvgnd_1
XFILLER_108_598 VGND VGND VPWR VPWR sky130_fd_sc_hd__decap_3
XFILLER_78_21 VGND VGND VPWR VPWR sky130_fd_sc_hd__decap_3
XFILLER_78_76 VGND VGND VPWR VPWR sky130_fd_sc_hd__decap_3
XFILLER_103_270 VGND VGND VPWR VPWR sky130_fd_sc_hd__fill_1
XFILLER_110_207 VGND VGND VPWR VPWR sky130_fd_sc_hd__decap_3
XFILLER_49_313 VGND VGND VPWR VPWR sky130_fd_sc_hd__decap_3
XFILLER_77_600 VGND VGND VPWR VPWR sky130_fd_sc_hd__decap_3
XFILLER_49_335 VGND VGND VPWR VPWR sky130_fd_sc_hd__fill_1
XFILLER_49_346 VGND VGND VPWR VPWR sky130_fd_sc_hd__decap_3
XFILLER_76_132 VGND VGND VPWR VPWR sky130_fd_sc_hd__fill_1
XFILLER_77_644 VGND VGND VPWR VPWR sky130_fd_sc_hd__decap_3
XFILLER_49_368 VGND VGND VPWR VPWR sky130_fd_sc_hd__decap_3
XFILLER_49_379 VGND VGND VPWR VPWR sky130_fd_sc_hd__decap_3
XFILLER_77_688 VGND VGND VPWR VPWR sky130_fd_sc_hd__decap_3
XFILLER_92_625 VGND VGND VPWR VPWR sky130_fd_sc_hd__decap_3
XFILLER_64_338 VGND VGND VPWR VPWR sky130_fd_sc_hd__fill_2
XFILLER_91_113 VGND VGND VPWR VPWR sky130_fd_sc_hd__decap_3
XFILLER_17_243 VGND VGND VPWR VPWR sky130_fd_sc_hd__decap_3
XFILLER_91_146 VGND VGND VPWR VPWR sky130_fd_sc_hd__fill_2
XFILLER_92_669 VGND VGND VPWR VPWR sky130_fd_sc_hd__decap_3
XFILLER_17_265 VGND VGND VPWR VPWR sky130_fd_sc_hd__decap_3
XFILLER_45_585 VGND VGND VPWR VPWR sky130_fd_sc_hd__decap_3
XFILLER_91_179 VGND VGND VPWR VPWR sky130_fd_sc_hd__decap_3
XTAP_TAPCELL_ROW_15_433 VGND VPWR sky130_fd_sc_hd__tapvpwrvgnd_1
XTAP_TAPCELL_ROW_43_764 VGND VPWR sky130_fd_sc_hd__tapvpwrvgnd_1
X_3680_ _3677_/Y _3926_/A2 _3902_/B1 _3679_/Y VGND VGND VPWR VPWR _3680_/X sky130_fd_sc_hd__a22o_2
XFILLER_9_486 VGND VGND VPWR VPWR sky130_fd_sc_hd__decap_3
X_5350_ _5350_/A0 _5131_/X _7412_/A VGND VGND VPWR VPWR _7156_/D sky130_fd_sc_hd__mux2_2
XFILLER_114_513 VGND VGND VPWR VPWR sky130_fd_sc_hd__decap_3
X_4301_ _7352_/Q _4338_/B1 _4318_/B1 _7160_/Q _4300_/X VGND VGND VPWR VPWR _4301_/X
+ sky130_fd_sc_hd__a221o_2
XFILLER_114_557 VGND VGND VPWR VPWR sky130_fd_sc_hd__decap_3
XFILLER_4_191 VGND VGND VPWR VPWR sky130_fd_sc_hd__decap_3
XFILLER_87_408 VGND VGND VPWR VPWR sky130_fd_sc_hd__decap_3
X_7020_ _7365_/CLK _7020_/D _6300_/Y VGND VGND VPWR VPWR _7020_/Q sky130_fd_sc_hd__dfrtp_2
X_4232_ _4228_/X _4231_/X _4327_/A VGND VGND VPWR VPWR _4628_/A sky130_fd_sc_hd__o21a_2
XFILLER_68_622 VGND VGND VPWR VPWR sky130_fd_sc_hd__decap_3
Xclkbuf_leaf_4_clk clkload0/A VGND VGND VPWR VPWR _6968_/CLK sky130_fd_sc_hd__clkbuf_16
XFILLER_67_110 VGND VGND VPWR VPWR sky130_fd_sc_hd__fill_2
XFILLER_68_666 VGND VGND VPWR VPWR sky130_fd_sc_hd__decap_3
X_4163_ _7073_/Q _4265_/B _4205_/A VGND VGND VPWR VPWR _4203_/B sky130_fd_sc_hd__o21a_2
XFILLER_67_154 VGND VGND VPWR VPWR sky130_fd_sc_hd__decap_3
XFILLER_83_603 VGND VGND VPWR VPWR sky130_fd_sc_hd__decap_3
X_4094_ _4095_/A _4210_/B VGND VGND VPWR VPWR _4096_/A sky130_fd_sc_hd__or2_2
XFILLER_83_647 VGND VGND VPWR VPWR sky130_fd_sc_hd__decap_3
XFILLER_36_563 VGND VGND VPWR VPWR sky130_fd_sc_hd__decap_3
XFILLER_51_511 VGND VGND VPWR VPWR sky130_fd_sc_hd__decap_3
XFILLER_82_179 VGND VGND VPWR VPWR sky130_fd_sc_hd__decap_3
XFILLER_63_393 VGND VGND VPWR VPWR sky130_fd_sc_hd__fill_1
Xplace382 _4420_/B1 VGND VGND VPWR VPWR _4428_/B1 sky130_fd_sc_hd__buf_2
Xplace371 _3556_/A VGND VGND VPWR VPWR _4248_/A sky130_fd_sc_hd__buf_2
Xplace360 _5108_/S VGND VGND VPWR VPWR _5080_/S sky130_fd_sc_hd__buf_2
X_6804_ _6941_/CLK _6804_/D VGND VGND VPWR VPWR _6804_/Q sky130_fd_sc_hd__dfxtp_2
X_4996_ _3833_/S _5657_/D _3817_/X _3346_/A VGND VGND VPWR VPWR _4996_/X sky130_fd_sc_hd__o211a_2
XFILLER_11_408 VGND VGND VPWR VPWR sky130_fd_sc_hd__decap_3
XFILLER_23_279 VGND VGND VPWR VPWR sky130_fd_sc_hd__fill_1
XFILLER_51_588 VGND VGND VPWR VPWR sky130_fd_sc_hd__decap_3
Xplace393 _3326_/A VGND VGND VPWR VPWR _5648_/A sky130_fd_sc_hd__buf_2
X_6735_ _6978_/CLK _6735_/D VGND VGND VPWR VPWR _6735_/Q sky130_fd_sc_hd__dfxtp_2
X_3947_ _7366_/Q _7334_/Q _3947_/S VGND VGND VPWR VPWR _7366_/D sky130_fd_sc_hd__mux2_2
X_6666_ _6672_/A VGND VGND VPWR VPWR _6666_/Y sky130_fd_sc_hd__inv_2
X_3878_ _6729_/Q _3878_/A2 _3892_/B1 _6741_/Q VGND VGND VPWR VPWR _3878_/X sky130_fd_sc_hd__a22o_2
X_6597_ _6630_/A VGND VGND VPWR VPWR _6597_/Y sky130_fd_sc_hd__inv_2
X_5617_ _5617_/A _5634_/B VGND VGND VPWR VPWR _7019_/D sky130_fd_sc_hd__and2_2
XFILLER_105_535 VGND VGND VPWR VPWR sky130_fd_sc_hd__decap_3
XFILLER_3_629 VGND VGND VPWR VPWR sky130_fd_sc_hd__decap_3
XFILLER_105_579 VGND VGND VPWR VPWR sky130_fd_sc_hd__decap_3
X_7218_ _7355_/CLK _7218_/D _6498_/Y VGND VGND VPWR VPWR _7218_/Q sky130_fd_sc_hd__dfrtp_2
XFILLER_59_600 VGND VGND VPWR VPWR sky130_fd_sc_hd__decap_3
XFILLER_58_121 VGND VGND VPWR VPWR sky130_fd_sc_hd__decap_3
XFILLER_59_644 VGND VGND VPWR VPWR sky130_fd_sc_hd__decap_3
XFILLER_86_430 VGND VGND VPWR VPWR sky130_fd_sc_hd__decap_3
XFILLER_86_441 VGND VGND VPWR VPWR sky130_fd_sc_hd__decap_3
X_7149_ _7372_/CLK _7149_/D _6429_/Y VGND VGND VPWR VPWR _7149_/Q sky130_fd_sc_hd__dfrtp_2
XFILLER_100_240 VGND VGND VPWR VPWR sky130_fd_sc_hd__decap_3
XFILLER_100_262 VGND VGND VPWR VPWR sky130_fd_sc_hd__fill_2
XFILLER_19_519 VGND VGND VPWR VPWR sky130_fd_sc_hd__decap_3
XFILLER_46_305 VGND VGND VPWR VPWR sky130_fd_sc_hd__decap_3
XFILLER_59_688 VGND VGND VPWR VPWR sky130_fd_sc_hd__decap_3
XFILLER_74_625 VGND VGND VPWR VPWR sky130_fd_sc_hd__decap_3
XFILLER_104_52 VGND VGND VPWR VPWR sky130_fd_sc_hd__decap_3
XFILLER_58_187 VGND VGND VPWR VPWR sky130_fd_sc_hd__decap_3
XFILLER_73_113 VGND VGND VPWR VPWR sky130_fd_sc_hd__decap_3
XPHY_EDGE_ROW_100_Left_217 VGND VGND VPWR VPWR sky130_fd_sc_hd__decap_3
XFILLER_104_85 VGND VGND VPWR VPWR sky130_fd_sc_hd__fill_2
XFILLER_104_96 VGND VGND VPWR VPWR sky130_fd_sc_hd__fill_1
XFILLER_39_390 VGND VGND VPWR VPWR sky130_fd_sc_hd__fill_2
XFILLER_61_308 VGND VGND VPWR VPWR sky130_fd_sc_hd__decap_3
XFILLER_64_23 VGND VGND VPWR VPWR sky130_fd_sc_hd__decap_3
XFILLER_74_669 VGND VGND VPWR VPWR sky130_fd_sc_hd__decap_3
XFILLER_27_585 VGND VGND VPWR VPWR sky130_fd_sc_hd__decap_3
XFILLER_54_371 VGND VGND VPWR VPWR sky130_fd_sc_hd__decap_3
XTAP_TAPCELL_ROW_64_1014 VGND VPWR sky130_fd_sc_hd__tapvpwrvgnd_1
XFILLER_14_224 VGND VGND VPWR VPWR sky130_fd_sc_hd__fill_1
XFILLER_42_533 VGND VGND VPWR VPWR sky130_fd_sc_hd__fill_1
XFILLER_81_190 VGND VGND VPWR VPWR sky130_fd_sc_hd__decap_3
XTAP_TAPCELL_ROW_64_1025 VGND VPWR sky130_fd_sc_hd__tapvpwrvgnd_1
XFILLER_42_566 VGND VGND VPWR VPWR sky130_fd_sc_hd__decap_3
XFILLER_80_11 VGND VGND VPWR VPWR sky130_fd_sc_hd__fill_1
Xfanout50 fanout73/A VGND VGND VPWR VPWR _6686_/A sky130_fd_sc_hd__clkdlybuf4s25_1
Xfanout61 _6622_/A VGND VGND VPWR VPWR _6654_/A sky130_fd_sc_hd__buf_2
Xfanout72 _6288_/A VGND VGND VPWR VPWR _6462_/A sky130_fd_sc_hd__buf_2
XTAP_TAPCELL_ROW_40_734 VGND VPWR sky130_fd_sc_hd__tapvpwrvgnd_1
XFILLER_13_60 VGND VGND VPWR VPWR sky130_fd_sc_hd__fill_1
XTAP_TAPCELL_ROW_20_491 VGND VPWR sky130_fd_sc_hd__tapvpwrvgnd_1
XFILLER_2_640 VGND VGND VPWR VPWR sky130_fd_sc_hd__decap_3
XFILLER_2_651 VGND VGND VPWR VPWR sky130_fd_sc_hd__decap_3
XFILLER_89_97 VGND VGND VPWR VPWR sky130_fd_sc_hd__decap_3
XTAP_TAPCELL_ROW_75_1154 VGND VPWR sky130_fd_sc_hd__tapvpwrvgnd_1
XFILLER_111_505 VGND VGND VPWR VPWR sky130_fd_sc_hd__decap_3
XFILLER_111_538 VGND VGND VPWR VPWR sky130_fd_sc_hd__decap_3
XFILLER_2_684 VGND VGND VPWR VPWR sky130_fd_sc_hd__decap_3
XFILLER_96_205 VGND VGND VPWR VPWR sky130_fd_sc_hd__decap_3
XFILLER_1_183 VGND VGND VPWR VPWR sky130_fd_sc_hd__decap_3
XFILLER_77_430 VGND VGND VPWR VPWR sky130_fd_sc_hd__fill_2
XFILLER_77_441 VGND VGND VPWR VPWR sky130_fd_sc_hd__decap_3
XFILLER_65_603 VGND VGND VPWR VPWR sky130_fd_sc_hd__decap_3
XFILLER_77_474 VGND VGND VPWR VPWR sky130_fd_sc_hd__decap_3
XFILLER_92_400 VGND VGND VPWR VPWR sky130_fd_sc_hd__decap_3
XFILLER_37_316 VGND VGND VPWR VPWR sky130_fd_sc_hd__decap_3
XFILLER_49_176 VGND VGND VPWR VPWR sky130_fd_sc_hd__decap_3
XFILLER_49_187 VGND VGND VPWR VPWR sky130_fd_sc_hd__decap_3
XFILLER_65_647 VGND VGND VPWR VPWR sky130_fd_sc_hd__decap_3
XFILLER_92_433 VGND VGND VPWR VPWR sky130_fd_sc_hd__decap_3
XTAP_TAPCELL_ROW_48_823 VGND VPWR sky130_fd_sc_hd__tapvpwrvgnd_1
XFILLER_92_477 VGND VGND VPWR VPWR sky130_fd_sc_hd__fill_1
Xclkbuf_3_7__f_clk clkbuf_0_clk/X VGND VGND VPWR VPWR clkload5/A sky130_fd_sc_hd__clkbuf_16
XFILLER_18_563 VGND VGND VPWR VPWR sky130_fd_sc_hd__decap_3
XFILLER_33_500 VGND VGND VPWR VPWR sky130_fd_sc_hd__decap_3
XFILLER_64_179 VGND VGND VPWR VPWR sky130_fd_sc_hd__fill_2
XFILLER_80_628 VGND VGND VPWR VPWR sky130_fd_sc_hd__decap_3
XFILLER_45_393 VGND VGND VPWR VPWR sky130_fd_sc_hd__fill_2
X_4850_ _4142_/X _4849_/Y _4633_/A VGND VGND VPWR VPWR _4850_/Y sky130_fd_sc_hd__o21ai_2
XTAP_TAPCELL_ROW_86_1283 VGND VPWR sky130_fd_sc_hd__tapvpwrvgnd_1
XTAP_TAPCELL_ROW_28_591 VGND VPWR sky130_fd_sc_hd__tapvpwrvgnd_1
XFILLER_33_588 VGND VGND VPWR VPWR sky130_fd_sc_hd__decap_3
XFILLER_60_374 VGND VGND VPWR VPWR sky130_fd_sc_hd__fill_2
X_3801_ _3735_/X _3798_/X _3800_/X _3714_/X VGND VGND VPWR VPWR _3801_/X sky130_fd_sc_hd__a22o_2
XFILLER_60_385 VGND VGND VPWR VPWR sky130_fd_sc_hd__decap_3
X_6520_ _6581_/A VGND VGND VPWR VPWR _6520_/Y sky130_fd_sc_hd__inv_2
X_4781_ _4444_/X _4780_/Y _4413_/A VGND VGND VPWR VPWR _4781_/X sky130_fd_sc_hd__o21a_2
XFILLER_20_249 VGND VGND VPWR VPWR sky130_fd_sc_hd__decap_3
X_3732_ _6776_/Q _3918_/A2 _3903_/A2 _6764_/Q _3731_/X VGND VGND VPWR VPWR _3732_/X
+ sky130_fd_sc_hd__a221o_2
Xclkload20 _6959_/CLK VGND VGND VPWR VPWR clkload20/X sky130_fd_sc_hd__clkbuf_8
X_6451_ _6652_/A VGND VGND VPWR VPWR _6451_/Y sky130_fd_sc_hd__inv_2
XFILLER_9_272 VGND VGND VPWR VPWR sky130_fd_sc_hd__decap_3
Xclkload31 _7362_/CLK VGND VGND VPWR VPWR clkload31/X sky130_fd_sc_hd__clkbuf_8
X_6382_ _6570_/A VGND VGND VPWR VPWR _6382_/Y sky130_fd_sc_hd__inv_2
X_5402_ _5402_/A0 _5027_/X _5409_/S VGND VGND VPWR VPWR _7132_/D sky130_fd_sc_hd__mux2_2
X_5333_ _5333_/A0 _5027_/X _5340_/S VGND VGND VPWR VPWR _7164_/D sky130_fd_sc_hd__mux2_2
X_3594_ _4292_/A _3594_/B VGND VGND VPWR VPWR _3594_/Y sky130_fd_sc_hd__nor2_2
XFILLER_102_516 VGND VGND VPWR VPWR sky130_fd_sc_hd__decap_3
X_5264_ _5264_/A0 _4997_/X _5286_/S VGND VGND VPWR VPWR _7198_/D sky130_fd_sc_hd__mux2_2
XFILLER_114_398 VGND VGND VPWR VPWR sky130_fd_sc_hd__decap_3
XFILLER_68_430 VGND VGND VPWR VPWR sky130_fd_sc_hd__decap_3
X_7003_ _7374_/CLK _7003_/D _6283_/Y VGND VGND VPWR VPWR _7003_/Q sky130_fd_sc_hd__dfrtp_2
X_4215_ _7260_/Q _4356_/A2 _4212_/X _4214_/X VGND VGND VPWR VPWR _4371_/A sky130_fd_sc_hd__a211o_2
XFILLER_110_560 VGND VGND VPWR VPWR sky130_fd_sc_hd__decap_3
X_4146_ _7234_/Q _4421_/A2 _4420_/B1 _7138_/Q VGND VGND VPWR VPWR _4146_/X sky130_fd_sc_hd__a22o_2
XFILLER_18_27 VGND VGND VPWR VPWR sky130_fd_sc_hd__fill_1
XFILLER_28_338 VGND VGND VPWR VPWR sky130_fd_sc_hd__decap_3
XFILLER_55_102 VGND VGND VPWR VPWR sky130_fd_sc_hd__fill_2
XFILLER_55_124 VGND VGND VPWR VPWR sky130_fd_sc_hd__decap_3
XFILLER_56_625 VGND VGND VPWR VPWR sky130_fd_sc_hd__decap_3
XFILLER_68_485 VGND VGND VPWR VPWR sky130_fd_sc_hd__decap_3
XFILLER_95_271 VGND VGND VPWR VPWR sky130_fd_sc_hd__decap_3
XFILLER_28_349 VGND VGND VPWR VPWR sky130_fd_sc_hd__fill_2
XFILLER_43_308 VGND VGND VPWR VPWR sky130_fd_sc_hd__decap_3
XFILLER_56_669 VGND VGND VPWR VPWR sky130_fd_sc_hd__decap_3
XFILLER_71_606 VGND VGND VPWR VPWR sky130_fd_sc_hd__decap_3
XFILLER_71_617 VGND VGND VPWR VPWR sky130_fd_sc_hd__decap_3
XFILLER_83_466 VGND VGND VPWR VPWR sky130_fd_sc_hd__decap_3
X_4077_ _7243_/Q _4433_/B _4434_/A2 _7115_/Q _4076_/X VGND VGND VPWR VPWR _4077_/X
+ sky130_fd_sc_hd__a221o_2
XFILLER_24_522 VGND VGND VPWR VPWR sky130_fd_sc_hd__fill_2
XFILLER_63_190 VGND VGND VPWR VPWR sky130_fd_sc_hd__decap_3
XFILLER_70_138 VGND VGND VPWR VPWR sky130_fd_sc_hd__fill_2
XFILLER_24_566 VGND VGND VPWR VPWR sky130_fd_sc_hd__decap_3
XFILLER_51_385 VGND VGND VPWR VPWR sky130_fd_sc_hd__decap_3
XFILLER_51_396 VGND VGND VPWR VPWR sky130_fd_sc_hd__decap_3
X_4979_ _4979_/A0 _4978_/X _4979_/S VGND VGND VPWR VPWR _7263_/D sky130_fd_sc_hd__mux2_2
Xclkload3 clkload3/A VGND VGND VPWR VPWR clkload3/X sky130_fd_sc_hd__clkbuf_16
X_6718_ _6965_/CLK _6718_/D VGND VGND VPWR VPWR _6718_/Q sky130_fd_sc_hd__dfxtp_2
X_6649_ _6649_/A VGND VGND VPWR VPWR _6649_/Y sky130_fd_sc_hd__inv_2
XFILLER_109_159 VGND VGND VPWR VPWR sky130_fd_sc_hd__decap_3
XFILLER_3_459 VGND VGND VPWR VPWR sky130_fd_sc_hd__decap_3
XFILLER_105_365 VGND VGND VPWR VPWR sky130_fd_sc_hd__decap_3
XFILLER_59_78 VGND VGND VPWR VPWR sky130_fd_sc_hd__decap_3
XFILLER_115_51 VGND VGND VPWR VPWR sky130_fd_sc_hd__decap_3
XFILLER_19_305 VGND VGND VPWR VPWR sky130_fd_sc_hd__decap_3
XFILLER_47_603 VGND VGND VPWR VPWR sky130_fd_sc_hd__decap_3
XFILLER_59_441 VGND VGND VPWR VPWR sky130_fd_sc_hd__decap_3
XFILLER_59_452 VGND VGND VPWR VPWR sky130_fd_sc_hd__decap_3
XFILLER_59_463 VGND VGND VPWR VPWR sky130_fd_sc_hd__decap_3
XFILLER_93_208 VGND VGND VPWR VPWR sky130_fd_sc_hd__decap_3
XFILLER_101_582 VGND VGND VPWR VPWR sky130_fd_sc_hd__decap_3
XFILLER_115_84 VGND VGND VPWR VPWR sky130_fd_sc_hd__decap_3
XFILLER_47_647 VGND VGND VPWR VPWR sky130_fd_sc_hd__decap_3
XFILLER_75_55 VGND VGND VPWR VPWR sky130_fd_sc_hd__fill_1
XTAP_TAPCELL_ROW_70_1095 VGND VPWR sky130_fd_sc_hd__tapvpwrvgnd_1
XTAP_TAPCELL_ROW_109_1559 VGND VPWR sky130_fd_sc_hd__tapvpwrvgnd_1
XFILLER_34_319 VGND VGND VPWR VPWR sky130_fd_sc_hd__decap_3
XFILLER_62_628 VGND VGND VPWR VPWR sky130_fd_sc_hd__decap_3
XFILLER_74_488 VGND VGND VPWR VPWR sky130_fd_sc_hd__decap_3
XFILLER_75_99 VGND VGND VPWR VPWR sky130_fd_sc_hd__decap_3
XFILLER_15_544 VGND VGND VPWR VPWR sky130_fd_sc_hd__decap_3
XFILLER_27_393 VGND VGND VPWR VPWR sky130_fd_sc_hd__decap_3
XFILLER_61_127 VGND VGND VPWR VPWR sky130_fd_sc_hd__fill_2
XFILLER_61_149 VGND VGND VPWR VPWR sky130_fd_sc_hd__decap_3
XFILLER_15_588 VGND VGND VPWR VPWR sky130_fd_sc_hd__decap_3
XFILLER_70_672 VGND VGND VPWR VPWR sky130_fd_sc_hd__decap_3
XFILLER_91_43 VGND VGND VPWR VPWR sky130_fd_sc_hd__fill_1
XTAP_TAPCELL_ROW_25_550 VGND VPWR sky130_fd_sc_hd__tapvpwrvgnd_1
XFILLER_30_514 VGND VGND VPWR VPWR sky130_fd_sc_hd__fill_2
XFILLER_30_525 VGND VGND VPWR VPWR sky130_fd_sc_hd__decap_3
XTAP_TAPCELL_ROW_53_892 VGND VPWR sky130_fd_sc_hd__tapvpwrvgnd_1
XFILLER_30_558 VGND VGND VPWR VPWR sky130_fd_sc_hd__decap_3
XFILLER_10_271 VGND VGND VPWR VPWR sky130_fd_sc_hd__decap_3
XFILLER_6_220 VGND VGND VPWR VPWR sky130_fd_sc_hd__decap_3
XFILLER_109_671 VGND VGND VPWR VPWR sky130_fd_sc_hd__fill_1
XFILLER_109_682 VGND VGND VPWR VPWR sky130_fd_sc_hd__decap_3
XFILLER_6_297 VGND VGND VPWR VPWR sky130_fd_sc_hd__decap_3
XFILLER_69_205 VGND VGND VPWR VPWR sky130_fd_sc_hd__decap_3
XFILLER_97_503 VGND VGND VPWR VPWR sky130_fd_sc_hd__fill_1
XFILLER_97_514 VGND VGND VPWR VPWR sky130_fd_sc_hd__decap_3
XFILLER_111_324 VGND VGND VPWR VPWR sky130_fd_sc_hd__decap_3
XFILLER_2_470 VGND VGND VPWR VPWR sky130_fd_sc_hd__decap_3
XFILLER_2_492 VGND VGND VPWR VPWR sky130_fd_sc_hd__decap_3
XFILLER_97_547 VGND VGND VPWR VPWR sky130_fd_sc_hd__decap_3
XFILLER_111_357 VGND VGND VPWR VPWR sky130_fd_sc_hd__decap_3
XFILLER_84_219 VGND VGND VPWR VPWR sky130_fd_sc_hd__decap_3
XFILLER_38_625 VGND VGND VPWR VPWR sky130_fd_sc_hd__decap_3
XFILLER_65_411 VGND VGND VPWR VPWR sky130_fd_sc_hd__decap_3
XFILLER_65_433 VGND VGND VPWR VPWR sky130_fd_sc_hd__decap_3
XFILLER_77_271 VGND VGND VPWR VPWR sky130_fd_sc_hd__decap_3
XTAP_TAPCELL_ROW_88_1312 VGND VPWR sky130_fd_sc_hd__tapvpwrvgnd_1
XFILLER_38_669 VGND VGND VPWR VPWR sky130_fd_sc_hd__decap_3
XFILLER_53_606 VGND VGND VPWR VPWR sky130_fd_sc_hd__decap_3
XFILLER_65_455 VGND VGND VPWR VPWR sky130_fd_sc_hd__decap_3
XFILLER_18_371 VGND VGND VPWR VPWR sky130_fd_sc_hd__decap_3
XFILLER_53_617 VGND VGND VPWR VPWR sky130_fd_sc_hd__decap_3
XFILLER_65_488 VGND VGND VPWR VPWR sky130_fd_sc_hd__decap_3
XFILLER_45_190 VGND VGND VPWR VPWR sky130_fd_sc_hd__decap_3
XFILLER_92_296 VGND VGND VPWR VPWR sky130_fd_sc_hd__decap_3
XFILLER_33_363 VGND VGND VPWR VPWR sky130_fd_sc_hd__decap_3
XFILLER_61_650 VGND VGND VPWR VPWR sky130_fd_sc_hd__decap_3
XFILLER_21_547 VGND VGND VPWR VPWR sky130_fd_sc_hd__decap_3
X_4833_ _7001_/Q _4687_/B _4983_/A VGND VGND VPWR VPWR _4834_/B sky130_fd_sc_hd__o21ai_2
X_4764_ _4938_/A _4764_/B VGND VGND VPWR VPWR _4788_/A sky130_fd_sc_hd__nor2_2
X_6503_ _6626_/A VGND VGND VPWR VPWR _6503_/Y sky130_fd_sc_hd__inv_2
XTAP_TAPCELL_ROW_99_1441 VGND VPWR sky130_fd_sc_hd__tapvpwrvgnd_1
X_6434_ _6602_/A VGND VGND VPWR VPWR _6434_/Y sky130_fd_sc_hd__inv_2
X_4695_ _7008_/Q _4728_/A _4694_/Y _4960_/A VGND VGND VPWR VPWR _4695_/X sky130_fd_sc_hd__a211o_2
XFILLER_115_641 VGND VGND VPWR VPWR sky130_fd_sc_hd__decap_3
X_6365_ _6683_/A VGND VGND VPWR VPWR _6365_/Y sky130_fd_sc_hd__inv_2
X_3577_ _7060_/Q _3577_/B VGND VGND VPWR VPWR _3591_/C sky130_fd_sc_hd__nor2_2
XFILLER_115_685 VGND VGND VPWR VPWR sky130_fd_sc_hd__decap_3
XFILLER_88_525 VGND VGND VPWR VPWR sky130_fd_sc_hd__decap_3
X_6296_ _6608_/A VGND VGND VPWR VPWR _6296_/Y sky130_fd_sc_hd__inv_2
XFILLER_88_536 VGND VGND VPWR VPWR sky130_fd_sc_hd__decap_3
X_5247_ _5247_/A0 _4864_/X _5262_/S VGND VGND VPWR VPWR _7206_/D sky130_fd_sc_hd__mux2_2
XFILLER_102_357 VGND VGND VPWR VPWR sky130_fd_sc_hd__decap_3
XFILLER_29_603 VGND VGND VPWR VPWR sky130_fd_sc_hd__decap_3
XFILLER_88_569 VGND VGND VPWR VPWR sky130_fd_sc_hd__decap_3
XFILLER_28_102 VGND VGND VPWR VPWR sky130_fd_sc_hd__decap_3
XFILLER_29_647 VGND VGND VPWR VPWR sky130_fd_sc_hd__decap_3
X_4129_ _7299_/Q _4491_/S _4419_/B1 _7363_/Q _4429_/C1 VGND VGND VPWR VPWR _4129_/X
+ sky130_fd_sc_hd__a221o_2
XFILLER_44_628 VGND VGND VPWR VPWR sky130_fd_sc_hd__decap_3
XFILLER_56_477 VGND VGND VPWR VPWR sky130_fd_sc_hd__decap_3
XFILLER_71_403 VGND VGND VPWR VPWR sky130_fd_sc_hd__fill_2
XFILLER_83_263 VGND VGND VPWR VPWR sky130_fd_sc_hd__fill_1
XTAP_TAPCELL_ROW_3_289 VGND VPWR sky130_fd_sc_hd__tapvpwrvgnd_1
XFILLER_71_447 VGND VGND VPWR VPWR sky130_fd_sc_hd__fill_1
XFILLER_71_458 VGND VGND VPWR VPWR sky130_fd_sc_hd__fill_2
XFILLER_101_42 VGND VGND VPWR VPWR sky130_fd_sc_hd__decap_3
XFILLER_24_341 VGND VGND VPWR VPWR sky130_fd_sc_hd__decap_3
XFILLER_52_672 VGND VGND VPWR VPWR sky130_fd_sc_hd__decap_3
XFILLER_12_536 VGND VGND VPWR VPWR sky130_fd_sc_hd__decap_3
XFILLER_61_24 VGND VGND VPWR VPWR sky130_fd_sc_hd__decap_3
XFILLER_12_569 VGND VGND VPWR VPWR sky130_fd_sc_hd__decap_3
XFILLER_61_57 VGND VGND VPWR VPWR sky130_fd_sc_hd__decap_3
XTAP_TAPCELL_ROW_50_851 VGND VPWR sky130_fd_sc_hd__tapvpwrvgnd_1
XTAP_TAPCELL_ROW_22_520 VGND VPWR sky130_fd_sc_hd__tapvpwrvgnd_1
XFILLER_3_223 VGND VGND VPWR VPWR sky130_fd_sc_hd__fill_1
XFILLER_106_663 VGND VGND VPWR VPWR sky130_fd_sc_hd__decap_3
XFILLER_79_514 VGND VGND VPWR VPWR sky130_fd_sc_hd__fill_1
XTAP_TAPCELL_ROW_72_1113 VGND VPWR sky130_fd_sc_hd__tapvpwrvgnd_1
XFILLER_79_536 VGND VGND VPWR VPWR sky130_fd_sc_hd__decap_3
XFILLER_94_506 VGND VGND VPWR VPWR sky130_fd_sc_hd__decap_3
XFILLER_19_113 VGND VGND VPWR VPWR sky130_fd_sc_hd__decap_3
XFILLER_47_422 VGND VGND VPWR VPWR sky130_fd_sc_hd__fill_1
XFILLER_59_271 VGND VGND VPWR VPWR sky130_fd_sc_hd__fill_2
XFILLER_87_591 VGND VGND VPWR VPWR sky130_fd_sc_hd__decap_3
XFILLER_94_539 VGND VGND VPWR VPWR sky130_fd_sc_hd__decap_3
XFILLER_59_293 VGND VGND VPWR VPWR sky130_fd_sc_hd__decap_3
XFILLER_74_230 VGND VGND VPWR VPWR sky130_fd_sc_hd__decap_3
XFILLER_74_241 VGND VGND VPWR VPWR sky130_fd_sc_hd__decap_3
XTAP_TAPCELL_ROW_58_951 VGND VPWR sky130_fd_sc_hd__tapvpwrvgnd_1
XFILLER_19_157 VGND VGND VPWR VPWR sky130_fd_sc_hd__decap_3
XFILLER_35_606 VGND VGND VPWR VPWR sky130_fd_sc_hd__decap_3
XFILLER_35_617 VGND VGND VPWR VPWR sky130_fd_sc_hd__decap_3
XFILLER_47_488 VGND VGND VPWR VPWR sky130_fd_sc_hd__fill_2
XFILLER_47_499 VGND VGND VPWR VPWR sky130_fd_sc_hd__fill_1
XFILLER_62_403 VGND VGND VPWR VPWR sky130_fd_sc_hd__decap_3
XFILLER_74_274 VGND VGND VPWR VPWR sky130_fd_sc_hd__decap_3
XFILLER_62_436 VGND VGND VPWR VPWR sky130_fd_sc_hd__decap_3
XFILLER_43_650 VGND VGND VPWR VPWR sky130_fd_sc_hd__decap_3
XTAP_TAPCELL_ROW_83_1253 VGND VPWR sky130_fd_sc_hd__tapvpwrvgnd_1
XTAP_TAPCELL_ROW_83_1242 VGND VPWR sky130_fd_sc_hd__tapvpwrvgnd_1
XFILLER_15_396 VGND VGND VPWR VPWR sky130_fd_sc_hd__fill_2
XFILLER_42_160 VGND VGND VPWR VPWR sky130_fd_sc_hd__decap_3
XFILLER_70_480 VGND VGND VPWR VPWR sky130_fd_sc_hd__fill_2
XFILLER_70_491 VGND VGND VPWR VPWR sky130_fd_sc_hd__decap_3
XFILLER_89_6 VGND VGND VPWR VPWR sky130_fd_sc_hd__decap_3
XFILLER_11_591 VGND VGND VPWR VPWR sky130_fd_sc_hd__decap_3
XFILLER_51_90 VGND VGND VPWR VPWR sky130_fd_sc_hd__decap_3
X_3500_ _4460_/A _4460_/B _3541_/B VGND VGND VPWR VPWR _3500_/Y sky130_fd_sc_hd__a21oi_2
XFILLER_7_573 VGND VGND VPWR VPWR sky130_fd_sc_hd__decap_3
X_4480_ _4480_/A0 _7307_/Q _4488_/S VGND VGND VPWR VPWR _4480_/X sky130_fd_sc_hd__mux2_2
X_3362_ _5129_/B _6983_/Q _3561_/A VGND VGND VPWR VPWR _3362_/X sky130_fd_sc_hd__or3b_2
XTAP_TAPCELL_ROW_94_1382 VGND VPWR sky130_fd_sc_hd__tapvpwrvgnd_1
XFILLER_112_622 VGND VGND VPWR VPWR sky130_fd_sc_hd__decap_3
XFILLER_97_322 VGND VGND VPWR VPWR sky130_fd_sc_hd__decap_3
X_5101_ _5101_/A _5101_/B VGND VGND VPWR VPWR _5101_/Y sky130_fd_sc_hd__nor2_2
XFILLER_111_143 VGND VGND VPWR VPWR sky130_fd_sc_hd__fill_2
XFILLER_112_666 VGND VGND VPWR VPWR sky130_fd_sc_hd__decap_3
Xhold1207 _7177_/Q VGND VGND VPWR VPWR _5306_/A0 sky130_fd_sc_hd__dlygate4sd3_1
XFILLER_57_219 VGND VGND VPWR VPWR sky130_fd_sc_hd__decap_3
XFILLER_85_539 VGND VGND VPWR VPWR sky130_fd_sc_hd__decap_3
XFILLER_97_388 VGND VGND VPWR VPWR sky130_fd_sc_hd__decap_3
XFILLER_97_399 VGND VGND VPWR VPWR sky130_fd_sc_hd__decap_3
Xhold1218 _7025_/Q VGND VGND VPWR VPWR _5605_/A sky130_fd_sc_hd__dlygate4sd3_1
X_5032_ _5032_/A _5032_/B VGND VGND VPWR VPWR _5032_/Y sky130_fd_sc_hd__xnor2_2
XFILLER_93_550 VGND VGND VPWR VPWR sky130_fd_sc_hd__decap_3
XFILLER_26_628 VGND VGND VPWR VPWR sky130_fd_sc_hd__decap_3
XFILLER_38_466 VGND VGND VPWR VPWR sky130_fd_sc_hd__fill_1
XFILLER_38_477 VGND VGND VPWR VPWR sky130_fd_sc_hd__decap_3
XFILLER_53_403 VGND VGND VPWR VPWR sky130_fd_sc_hd__decap_3
XFILLER_65_263 VGND VGND VPWR VPWR sky130_fd_sc_hd__decap_3
XFILLER_93_561 VGND VGND VPWR VPWR sky130_fd_sc_hd__decap_3
XFILLER_25_138 VGND VGND VPWR VPWR sky130_fd_sc_hd__decap_3
XFILLER_80_211 VGND VGND VPWR VPWR sky130_fd_sc_hd__decap_3
XFILLER_80_233 VGND VGND VPWR VPWR sky130_fd_sc_hd__decap_3
XFILLER_93_594 VGND VGND VPWR VPWR sky130_fd_sc_hd__decap_3
X_6983_ clkload7/A _6983_/D _6263_/Y VGND VGND VPWR VPWR _6983_/Q sky130_fd_sc_hd__dfrtp_2
XTAP_TAPCELL_ROW_0_248 VGND VPWR sky130_fd_sc_hd__tapvpwrvgnd_1
XTAP_TAPCELL_ROW_0_237 VGND VPWR sky130_fd_sc_hd__tapvpwrvgnd_1
XFILLER_41_609 VGND VGND VPWR VPWR sky130_fd_sc_hd__decap_3
XFILLER_53_458 VGND VGND VPWR VPWR sky130_fd_sc_hd__decap_3
XTAP_TAPCELL_ROW_36_678 VGND VPWR sky130_fd_sc_hd__tapvpwrvgnd_1
XFILLER_34_672 VGND VGND VPWR VPWR sky130_fd_sc_hd__decap_3
XTAP_TAPCELL_ROW_36_689 VGND VPWR sky130_fd_sc_hd__tapvpwrvgnd_1
XFILLER_21_333 VGND VGND VPWR VPWR sky130_fd_sc_hd__decap_3
X_4816_ _4970_/A1 _4652_/A _4813_/A _5033_/B2 VGND VGND VPWR VPWR _4816_/X sky130_fd_sc_hd__a22o_2
XFILLER_21_399 VGND VGND VPWR VPWR sky130_fd_sc_hd__fill_1
X_4747_ _4739_/Y _4740_/X _4743_/X _4746_/X VGND VGND VPWR VPWR _5664_/B sky130_fd_sc_hd__o211a_2
XFILLER_107_438 VGND VGND VPWR VPWR sky130_fd_sc_hd__decap_3
XFILLER_110_9 VGND VGND VPWR VPWR sky130_fd_sc_hd__decap_3
X_4678_ _6988_/Q _4674_/X _5045_/B _5036_/A VGND VGND VPWR VPWR _5014_/B sky130_fd_sc_hd__a31o_2
XFILLER_107_449 VGND VGND VPWR VPWR sky130_fd_sc_hd__decap_3
X_7397_ _7404_/CLK _7397_/D _6677_/Y VGND VGND VPWR VPWR _7397_/Q sky130_fd_sc_hd__dfrtp_2
X_6417_ _6643_/A VGND VGND VPWR VPWR _6417_/Y sky130_fd_sc_hd__inv_2
X_3629_ _3629_/A VGND VGND VPWR VPWR _3629_/Y sky130_fd_sc_hd__inv_2
XFILLER_103_600 VGND VGND VPWR VPWR sky130_fd_sc_hd__decap_3
X_6348_ _6672_/A VGND VGND VPWR VPWR _6348_/Y sky130_fd_sc_hd__inv_2
XFILLER_103_644 VGND VGND VPWR VPWR sky130_fd_sc_hd__decap_3
XFILLER_115_482 VGND VGND VPWR VPWR sky130_fd_sc_hd__decap_3
XTAP_TAPCELL_ROW_8_348 VGND VPWR sky130_fd_sc_hd__tapvpwrvgnd_1
XFILLER_102_121 VGND VGND VPWR VPWR sky130_fd_sc_hd__decap_3
XFILLER_88_377 VGND VGND VPWR VPWR sky130_fd_sc_hd__decap_3
X_6279_ _6462_/A VGND VGND VPWR VPWR _6279_/Y sky130_fd_sc_hd__inv_2
XFILLER_103_688 VGND VGND VPWR VPWR sky130_fd_sc_hd__decap_3
XFILLER_48_219 VGND VGND VPWR VPWR sky130_fd_sc_hd__decap_3
XFILLER_76_539 VGND VGND VPWR VPWR sky130_fd_sc_hd__decap_3
XFILLER_56_24 VGND VGND VPWR VPWR sky130_fd_sc_hd__decap_3
XFILLER_56_35 VGND VGND VPWR VPWR sky130_fd_sc_hd__fill_2
XFILLER_69_591 VGND VGND VPWR VPWR sky130_fd_sc_hd__decap_3
XFILLER_17_606 VGND VGND VPWR VPWR sky130_fd_sc_hd__decap_3
XFILLER_17_617 VGND VGND VPWR VPWR sky130_fd_sc_hd__decap_3
XFILLER_84_572 VGND VGND VPWR VPWR sky130_fd_sc_hd__decap_3
XTAP_TAPCELL_ROW_55_910 VGND VPWR sky130_fd_sc_hd__tapvpwrvgnd_1
XTAP_TAPCELL_ROW_106_1518 VGND VPWR sky130_fd_sc_hd__tapvpwrvgnd_1
XFILLER_112_41 VGND VGND VPWR VPWR sky130_fd_sc_hd__decap_3
XFILLER_56_285 VGND VGND VPWR VPWR sky130_fd_sc_hd__decap_3
XTAP_TAPCELL_ROW_106_1529 VGND VPWR sky130_fd_sc_hd__tapvpwrvgnd_1
XFILLER_112_74 VGND VGND VPWR VPWR sky130_fd_sc_hd__decap_3
XFILLER_112_85 VGND VGND VPWR VPWR sky130_fd_sc_hd__fill_1
XFILLER_25_650 VGND VGND VPWR VPWR sky130_fd_sc_hd__decap_3
XFILLER_72_12 VGND VGND VPWR VPWR sky130_fd_sc_hd__decap_3
XFILLER_24_171 VGND VGND VPWR VPWR sky130_fd_sc_hd__decap_3
XFILLER_52_480 VGND VGND VPWR VPWR sky130_fd_sc_hd__decap_3
XFILLER_71_277 VGND VGND VPWR VPWR sky130_fd_sc_hd__decap_3
XFILLER_40_631 VGND VGND VPWR VPWR sky130_fd_sc_hd__decap_3
XFILLER_12_355 VGND VGND VPWR VPWR sky130_fd_sc_hd__decap_3
XFILLER_40_675 VGND VGND VPWR VPWR sky130_fd_sc_hd__decap_3
XFILLER_8_315 VGND VGND VPWR VPWR sky130_fd_sc_hd__decap_3
XFILLER_8_337 VGND VGND VPWR VPWR sky130_fd_sc_hd__decap_3
XFILLER_12_399 VGND VGND VPWR VPWR sky130_fd_sc_hd__fill_1
XFILLER_4_510 VGND VGND VPWR VPWR sky130_fd_sc_hd__decap_3
XFILLER_99_609 VGND VGND VPWR VPWR sky130_fd_sc_hd__decap_3
XFILLER_106_460 VGND VGND VPWR VPWR sky130_fd_sc_hd__decap_3
XFILLER_113_408 VGND VGND VPWR VPWR sky130_fd_sc_hd__decap_3
XFILLER_4_554 VGND VGND VPWR VPWR sky130_fd_sc_hd__decap_3
XFILLER_4_587 VGND VGND VPWR VPWR sky130_fd_sc_hd__fill_1
XFILLER_4_598 VGND VGND VPWR VPWR sky130_fd_sc_hd__decap_3
XFILLER_94_347 VGND VGND VPWR VPWR sky130_fd_sc_hd__decap_3
XFILLER_94_358 VGND VGND VPWR VPWR sky130_fd_sc_hd__decap_3
XFILLER_94_369 VGND VGND VPWR VPWR sky130_fd_sc_hd__decap_3
XFILLER_47_263 VGND VGND VPWR VPWR sky130_fd_sc_hd__decap_3
XFILLER_75_550 VGND VGND VPWR VPWR sky130_fd_sc_hd__decap_3
XFILLER_75_561 VGND VGND VPWR VPWR sky130_fd_sc_hd__decap_3
XFILLER_35_447 VGND VGND VPWR VPWR sky130_fd_sc_hd__fill_1
XFILLER_47_296 VGND VGND VPWR VPWR sky130_fd_sc_hd__decap_3
XFILLER_62_200 VGND VGND VPWR VPWR sky130_fd_sc_hd__decap_3
XFILLER_75_594 VGND VGND VPWR VPWR sky130_fd_sc_hd__decap_3
XFILLER_90_542 VGND VGND VPWR VPWR sky130_fd_sc_hd__decap_3
XFILLER_23_609 VGND VGND VPWR VPWR sky130_fd_sc_hd__decap_3
XFILLER_62_244 VGND VGND VPWR VPWR sky130_fd_sc_hd__fill_1
XFILLER_90_575 VGND VGND VPWR VPWR sky130_fd_sc_hd__decap_3
XFILLER_16_672 VGND VGND VPWR VPWR sky130_fd_sc_hd__decap_3
XFILLER_31_620 VGND VGND VPWR VPWR sky130_fd_sc_hd__decap_3
XFILLER_50_439 VGND VGND VPWR VPWR sky130_fd_sc_hd__fill_2
XFILLER_62_299 VGND VGND VPWR VPWR sky130_fd_sc_hd__decap_3
XFILLER_31_653 VGND VGND VPWR VPWR sky130_fd_sc_hd__decap_3
Xclkbuf_0_clk clk VGND VGND VPWR VPWR clkbuf_0_clk/X sky130_fd_sc_hd__clkbuf_16
X_5650_ _5650_/A VGND VGND VPWR VPWR _5650_/Y sky130_fd_sc_hd__inv_2
XTAP_TAPCELL_ROW_61_979 VGND VPWR sky130_fd_sc_hd__tapvpwrvgnd_1
XTAP_TAPCELL_ROW_33_648 VGND VPWR sky130_fd_sc_hd__tapvpwrvgnd_1
X_4601_ _4601_/A0 _5157_/A0 _4601_/S VGND VGND VPWR VPWR _7280_/D sky130_fd_sc_hd__mux2_2
X_5581_ _5581_/A0 _5069_/X _5593_/B VGND VGND VPWR VPWR _7038_/D sky130_fd_sc_hd__mux2_2
XTAP_TAPCELL_ROW_96_1400 VGND VPWR sky130_fd_sc_hd__tapvpwrvgnd_1
XFILLER_116_213 VGND VGND VPWR VPWR sky130_fd_sc_hd__decap_3
X_7320_ _7351_/CLK _7320_/D _6600_/Y VGND VGND VPWR VPWR _7320_/Q sky130_fd_sc_hd__dfrtp_2
X_4532_ _4532_/A0 _7281_/Q _4532_/S VGND VGND VPWR VPWR _4532_/X sky130_fd_sc_hd__mux2_2
XFILLER_116_235 VGND VGND VPWR VPWR sky130_fd_sc_hd__decap_3
X_7251_ _7350_/CLK _7251_/D _6531_/Y VGND VGND VPWR VPWR _7251_/Q sky130_fd_sc_hd__dfrtp_2
X_4463_ _4460_/Y _3541_/B _5057_/A _4462_/Y VGND VGND VPWR VPWR _4463_/X sky130_fd_sc_hd__a22o_2
XFILLER_104_419 VGND VGND VPWR VPWR sky130_fd_sc_hd__fill_1
XFILLER_116_268 VGND VGND VPWR VPWR sky130_fd_sc_hd__decap_3
XFILLER_116_279 VGND VGND VPWR VPWR sky130_fd_sc_hd__fill_1
XFILLER_89_119 VGND VGND VPWR VPWR sky130_fd_sc_hd__decap_3
X_3414_ _3421_/C VGND VGND VPWR VPWR _3449_/C sky130_fd_sc_hd__inv_4
X_7182_ _7374_/CLK _7182_/D _6462_/Y VGND VGND VPWR VPWR _7182_/Q sky130_fd_sc_hd__dfrtp_2
X_4394_ _4394_/A _4394_/B _4393_/X VGND VGND VPWR VPWR _4444_/B sky130_fd_sc_hd__or3b_2
XPHY_EDGE_ROW_15_Right_15 VGND VGND VPWR VPWR sky130_fd_sc_hd__decap_3
XFILLER_98_631 VGND VGND VPWR VPWR sky130_fd_sc_hd__decap_3
XFILLER_112_430 VGND VGND VPWR VPWR sky130_fd_sc_hd__decap_3
XFILLER_97_141 VGND VGND VPWR VPWR sky130_fd_sc_hd__decap_3
X_3345_ _5642_/A _4677_/B VGND VGND VPWR VPWR _3346_/A sky130_fd_sc_hd__nor2_4
XTAP_TAPCELL_ROW_5_307 VGND VPWR sky130_fd_sc_hd__tapvpwrvgnd_1
XFILLER_98_675 VGND VGND VPWR VPWR sky130_fd_sc_hd__decap_3
XFILLER_100_625 VGND VGND VPWR VPWR sky130_fd_sc_hd__decap_3
XFILLER_112_463 VGND VGND VPWR VPWR sky130_fd_sc_hd__decap_3
Xhold1004 _7266_/Q VGND VGND VPWR VPWR _4933_/A0 sky130_fd_sc_hd__dlygate4sd3_1
Xhold1015 _7197_/Q VGND VGND VPWR VPWR _5266_/A0 sky130_fd_sc_hd__dlygate4sd3_1
XFILLER_100_669 VGND VGND VPWR VPWR sky130_fd_sc_hd__decap_3
XFILLER_97_196 VGND VGND VPWR VPWR sky130_fd_sc_hd__decap_3
Xhold1026 _7204_/Q VGND VGND VPWR VPWR _5251_/A0 sky130_fd_sc_hd__dlygate4sd3_1
Xhold1037 _7255_/Q VGND VGND VPWR VPWR _5108_/A0 sky130_fd_sc_hd__dlygate4sd3_1
Xhold1048 _6716_/Q VGND VGND VPWR VPWR _5733_/A1 sky130_fd_sc_hd__dlygate4sd3_1
X_5015_ _5117_/A _5015_/B _5015_/C VGND VGND VPWR VPWR _5015_/X sky130_fd_sc_hd__and3_2
XFILLER_38_241 VGND VGND VPWR VPWR sky130_fd_sc_hd__decap_3
XFILLER_66_572 VGND VGND VPWR VPWR sky130_fd_sc_hd__decap_3
Xhold1059 _7278_/Q VGND VGND VPWR VPWR _4718_/A0 sky130_fd_sc_hd__dlygate4sd3_1
XFILLER_26_414 VGND VGND VPWR VPWR sky130_fd_sc_hd__decap_3
XFILLER_38_285 VGND VGND VPWR VPWR sky130_fd_sc_hd__decap_3
XFILLER_53_222 VGND VGND VPWR VPWR sky130_fd_sc_hd__fill_2
XFILLER_26_469 VGND VGND VPWR VPWR sky130_fd_sc_hd__fill_2
XFILLER_53_244 VGND VGND VPWR VPWR sky130_fd_sc_hd__decap_3
XFILLER_53_255 VGND VGND VPWR VPWR sky130_fd_sc_hd__decap_3
XFILLER_81_542 VGND VGND VPWR VPWR sky130_fd_sc_hd__decap_3
XFILLER_81_564 VGND VGND VPWR VPWR sky130_fd_sc_hd__decap_3
X_6966_ _6966_/CLK _6966_/D VGND VGND VPWR VPWR _6966_/Q sky130_fd_sc_hd__dfxtp_2
XPHY_EDGE_ROW_24_Right_24 VGND VGND VPWR VPWR sky130_fd_sc_hd__decap_3
XFILLER_53_299 VGND VGND VPWR VPWR sky130_fd_sc_hd__decap_3
XFILLER_81_597 VGND VGND VPWR VPWR sky130_fd_sc_hd__decap_3
XFILLER_22_631 VGND VGND VPWR VPWR sky130_fd_sc_hd__decap_3
XFILLER_34_480 VGND VGND VPWR VPWR sky130_fd_sc_hd__decap_3
X_6897_ _6966_/CLK _6897_/D VGND VGND VPWR VPWR _6897_/Q sky130_fd_sc_hd__dfxtp_2
XFILLER_22_675 VGND VGND VPWR VPWR sky130_fd_sc_hd__decap_3
XFILLER_42_59 VGND VGND VPWR VPWR sky130_fd_sc_hd__decap_3
XTAP_TAPCELL_ROW_101_1459 VGND VPWR sky130_fd_sc_hd__tapvpwrvgnd_1
XFILLER_5_307 VGND VGND VPWR VPWR sky130_fd_sc_hd__decap_3
XFILLER_5_329 VGND VGND VPWR VPWR sky130_fd_sc_hd__decap_3
XFILLER_107_213 VGND VGND VPWR VPWR sky130_fd_sc_hd__fill_2
XFILLER_1_502 VGND VGND VPWR VPWR sky130_fd_sc_hd__fill_2
XPHY_EDGE_ROW_33_Right_33 VGND VGND VPWR VPWR sky130_fd_sc_hd__decap_3
XFILLER_107_30 VGND VGND VPWR VPWR sky130_fd_sc_hd__decap_3
XFILLER_1_535 VGND VGND VPWR VPWR sky130_fd_sc_hd__decap_3
XFILLER_89_620 VGND VGND VPWR VPWR sky130_fd_sc_hd__decap_3
Xhold860 _7094_/Q VGND VGND VPWR VPWR _7094_/D sky130_fd_sc_hd__dlygate4sd3_1
Xhold871 _7106_/Q VGND VGND VPWR VPWR _7106_/D sky130_fd_sc_hd__dlygate4sd3_1
Xhold882 _7099_/Q VGND VGND VPWR VPWR _7099_/D sky130_fd_sc_hd__dlygate4sd3_1
XFILLER_67_23 VGND VGND VPWR VPWR sky130_fd_sc_hd__decap_3
XFILLER_88_130 VGND VGND VPWR VPWR sky130_fd_sc_hd__decap_3
XFILLER_88_141 VGND VGND VPWR VPWR sky130_fd_sc_hd__decap_3
XFILLER_89_653 VGND VGND VPWR VPWR sky130_fd_sc_hd__decap_3
Xhold893 _7100_/Q VGND VGND VPWR VPWR _7100_/D sky130_fd_sc_hd__dlygate4sd3_1
XFILLER_103_474 VGND VGND VPWR VPWR sky130_fd_sc_hd__decap_3
XTAP_TAPCELL_ROW_112_1599 VGND VPWR sky130_fd_sc_hd__tapvpwrvgnd_1
XFILLER_76_336 VGND VGND VPWR VPWR sky130_fd_sc_hd__fill_1
XFILLER_29_252 VGND VGND VPWR VPWR sky130_fd_sc_hd__decap_3
XFILLER_57_561 VGND VGND VPWR VPWR sky130_fd_sc_hd__decap_3
XFILLER_91_306 VGND VGND VPWR VPWR sky130_fd_sc_hd__fill_1
XFILLER_91_317 VGND VGND VPWR VPWR sky130_fd_sc_hd__decap_3
XFILLER_17_414 VGND VGND VPWR VPWR sky130_fd_sc_hd__fill_2
XFILLER_29_296 VGND VGND VPWR VPWR sky130_fd_sc_hd__decap_3
XFILLER_57_594 VGND VGND VPWR VPWR sky130_fd_sc_hd__decap_3
XFILLER_83_11 VGND VGND VPWR VPWR sky130_fd_sc_hd__fill_1
XPHY_EDGE_ROW_42_Right_42 VGND VGND VPWR VPWR sky130_fd_sc_hd__decap_3
XFILLER_17_447 VGND VGND VPWR VPWR sky130_fd_sc_hd__fill_1
XFILLER_72_553 VGND VGND VPWR VPWR sky130_fd_sc_hd__decap_3
XTAP_TAPCELL_ROW_67_1056 VGND VPWR sky130_fd_sc_hd__tapvpwrvgnd_1
XFILLER_32_439 VGND VGND VPWR VPWR sky130_fd_sc_hd__decap_3
XFILLER_72_586 VGND VGND VPWR VPWR sky130_fd_sc_hd__fill_2
XFILLER_83_88 VGND VGND VPWR VPWR sky130_fd_sc_hd__decap_3
XFILLER_13_620 VGND VGND VPWR VPWR sky130_fd_sc_hd__decap_3
XFILLER_13_653 VGND VGND VPWR VPWR sky130_fd_sc_hd__decap_3
XTAP_TAPCELL_ROW_80_1212 VGND VPWR sky130_fd_sc_hd__tapvpwrvgnd_1
XFILLER_12_141 VGND VGND VPWR VPWR sky130_fd_sc_hd__decap_3
XTAP_TAPCELL_ROW_30_607 VGND VPWR sky130_fd_sc_hd__tapvpwrvgnd_1
XFILLER_9_635 VGND VGND VPWR VPWR sky130_fd_sc_hd__decap_3
XFILLER_40_483 VGND VGND VPWR VPWR sky130_fd_sc_hd__decap_3
XFILLER_9_668 VGND VGND VPWR VPWR sky130_fd_sc_hd__decap_3
XFILLER_32_81 VGND VGND VPWR VPWR sky130_fd_sc_hd__decap_3
XFILLER_8_156 VGND VGND VPWR VPWR sky130_fd_sc_hd__decap_3
XPHY_EDGE_ROW_51_Right_51 VGND VGND VPWR VPWR sky130_fd_sc_hd__decap_3
XFILLER_9_679 VGND VGND VPWR VPWR sky130_fd_sc_hd__decap_3
XTAP_TAPCELL_ROW_10_375 VGND VPWR sky130_fd_sc_hd__tapvpwrvgnd_1
XFILLER_113_205 VGND VGND VPWR VPWR sky130_fd_sc_hd__decap_3
XTAP_TAPCELL_ROW_78_1185 VGND VPWR sky130_fd_sc_hd__tapvpwrvgnd_1
XTAP_TAPCELL_ROW_91_1341 VGND VPWR sky130_fd_sc_hd__tapvpwrvgnd_1
XFILLER_67_325 VGND VGND VPWR VPWR sky130_fd_sc_hd__fill_2
XFILLER_79_163 VGND VGND VPWR VPWR sky130_fd_sc_hd__decap_3
XFILLER_95_612 VGND VGND VPWR VPWR sky130_fd_sc_hd__decap_3
XFILLER_95_623 VGND VGND VPWR VPWR sky130_fd_sc_hd__decap_3
XFILLER_95_656 VGND VGND VPWR VPWR sky130_fd_sc_hd__decap_3
XFILLER_82_306 VGND VGND VPWR VPWR sky130_fd_sc_hd__fill_2
XFILLER_94_177 VGND VGND VPWR VPWR sky130_fd_sc_hd__decap_3
XTAP_TAPCELL_ROW_38_707 VGND VPWR sky130_fd_sc_hd__tapvpwrvgnd_1
XPHY_EDGE_ROW_60_Right_60 VGND VGND VPWR VPWR sky130_fd_sc_hd__decap_3
XFILLER_82_339 VGND VGND VPWR VPWR sky130_fd_sc_hd__decap_3
XFILLER_63_542 VGND VGND VPWR VPWR sky130_fd_sc_hd__decap_3
XFILLER_63_564 VGND VGND VPWR VPWR sky130_fd_sc_hd__decap_3
X_6820_ clkload9/A _6820_/D VGND VGND VPWR VPWR _6820_/Q sky130_fd_sc_hd__dfxtp_2
XFILLER_23_406 VGND VGND VPWR VPWR sky130_fd_sc_hd__fill_2
XFILLER_23_428 VGND VGND VPWR VPWR sky130_fd_sc_hd__fill_2
XFILLER_35_266 VGND VGND VPWR VPWR sky130_fd_sc_hd__decap_3
XFILLER_63_597 VGND VGND VPWR VPWR sky130_fd_sc_hd__decap_3
XTAP_TAPCELL_ROW_18_464 VGND VPWR sky130_fd_sc_hd__tapvpwrvgnd_1
XFILLER_16_480 VGND VGND VPWR VPWR sky130_fd_sc_hd__fill_1
X_6751_ clkload9/A _6751_/D VGND VGND VPWR VPWR _6751_/Q sky130_fd_sc_hd__dfxtp_2
XFILLER_31_461 VGND VGND VPWR VPWR sky130_fd_sc_hd__decap_3
X_6682_ _6685_/A VGND VGND VPWR VPWR _6682_/Y sky130_fd_sc_hd__inv_2
X_3894_ _3728_/Y _3891_/X _3893_/X _3733_/X VGND VGND VPWR VPWR _3894_/X sky130_fd_sc_hd__a22o_2
X_5633_ _5633_/A _5633_/B VGND VGND VPWR VPWR _7012_/D sky130_fd_sc_hd__nor2_2
XFILLER_12_29 VGND VGND VPWR VPWR sky130_fd_sc_hd__decap_3
X_5564_ hold956/X _4960_/A _4751_/B VGND VGND VPWR VPWR _7052_/D sky130_fd_sc_hd__a21bo_2
XFILLER_8_690 VGND VGND VPWR VPWR sky130_fd_sc_hd__fill_1
X_7303_ _7372_/CLK _7303_/D _6583_/Y VGND VGND VPWR VPWR _7303_/Q sky130_fd_sc_hd__dfrtp_2
X_4515_ _4515_/A0 _7290_/Q _4517_/S VGND VGND VPWR VPWR _7322_/D sky130_fd_sc_hd__mux2_2
XPHY_EDGE_ROW_103_Right_103 VGND VGND VPWR VPWR sky130_fd_sc_hd__decap_3
X_7234_ _7332_/CLK _7234_/D _6514_/Y VGND VGND VPWR VPWR _7234_/Q sky130_fd_sc_hd__dfrtp_2
X_4446_ _4446_/A _4814_/B VGND VGND VPWR VPWR _4447_/B sky130_fd_sc_hd__nor2_2
X_7165_ _7322_/CLK _7165_/D _6445_/Y VGND VGND VPWR VPWR _7165_/Q sky130_fd_sc_hd__dfrtp_2
X_4377_ _4275_/Y _4375_/X _4376_/X VGND VGND VPWR VPWR _4377_/Y sky130_fd_sc_hd__o21ai_2
XFILLER_85_100 VGND VGND VPWR VPWR sky130_fd_sc_hd__decap_3
XFILLER_86_601 VGND VGND VPWR VPWR sky130_fd_sc_hd__decap_3
X_3328_ _3328_/A _3328_/B VGND VGND VPWR VPWR _3340_/C sky130_fd_sc_hd__nor2_2
XPHY_EDGE_ROW_13_Left_130 VGND VGND VPWR VPWR sky130_fd_sc_hd__decap_3
XFILLER_98_483 VGND VGND VPWR VPWR sky130_fd_sc_hd__decap_3
XFILLER_112_271 VGND VGND VPWR VPWR sky130_fd_sc_hd__decap_3
XFILLER_85_122 VGND VGND VPWR VPWR sky130_fd_sc_hd__decap_3
XFILLER_86_634 VGND VGND VPWR VPWR sky130_fd_sc_hd__decap_3
XFILLER_86_645 VGND VGND VPWR VPWR sky130_fd_sc_hd__decap_3
X_7096_ _7355_/CLK _7096_/D _6376_/Y VGND VGND VPWR VPWR _7096_/Q sky130_fd_sc_hd__dfrtp_2
XFILLER_100_477 VGND VGND VPWR VPWR sky130_fd_sc_hd__decap_3
XFILLER_39_561 VGND VGND VPWR VPWR sky130_fd_sc_hd__decap_3
XFILLER_85_166 VGND VGND VPWR VPWR sky130_fd_sc_hd__fill_2
XFILLER_86_678 VGND VGND VPWR VPWR sky130_fd_sc_hd__decap_3
XFILLER_26_200 VGND VGND VPWR VPWR sky130_fd_sc_hd__fill_1
XFILLER_39_594 VGND VGND VPWR VPWR sky130_fd_sc_hd__decap_3
XFILLER_85_188 VGND VGND VPWR VPWR sky130_fd_sc_hd__decap_3
XFILLER_53_36 VGND VGND VPWR VPWR sky130_fd_sc_hd__decap_3
XFILLER_54_575 VGND VGND VPWR VPWR sky130_fd_sc_hd__decap_3
XFILLER_14_439 VGND VGND VPWR VPWR sky130_fd_sc_hd__fill_1
XFILLER_41_225 VGND VGND VPWR VPWR sky130_fd_sc_hd__decap_3
X_6949_ _6970_/CLK _6949_/D VGND VGND VPWR VPWR _6949_/Q sky130_fd_sc_hd__dfxtp_2
XFILLER_10_601 VGND VGND VPWR VPWR sky130_fd_sc_hd__decap_3
XFILLER_41_258 VGND VGND VPWR VPWR sky130_fd_sc_hd__decap_3
XFILLER_10_634 VGND VGND VPWR VPWR sky130_fd_sc_hd__decap_3
XFILLER_10_645 VGND VGND VPWR VPWR sky130_fd_sc_hd__decap_3
XFILLER_22_483 VGND VGND VPWR VPWR sky130_fd_sc_hd__fill_1
XFILLER_10_678 VGND VGND VPWR VPWR sky130_fd_sc_hd__decap_3
XFILLER_6_616 VGND VGND VPWR VPWR sky130_fd_sc_hd__decap_3
XFILLER_108_522 VGND VGND VPWR VPWR sky130_fd_sc_hd__decap_3
XFILLER_108_533 VGND VGND VPWR VPWR sky130_fd_sc_hd__decap_3
XFILLER_108_566 VGND VGND VPWR VPWR sky130_fd_sc_hd__decap_3
XTAP_TAPCELL_ROW_114_1617 VGND VPWR sky130_fd_sc_hd__tapvpwrvgnd_1
XFILLER_1_310 VGND VGND VPWR VPWR sky130_fd_sc_hd__fill_1
Xhold690 _6727_/Q VGND VGND VPWR VPWR _6727_/D sky130_fd_sc_hd__dlygate4sd3_1
XFILLER_77_612 VGND VGND VPWR VPWR sky130_fd_sc_hd__decap_3
XFILLER_77_623 VGND VGND VPWR VPWR sky130_fd_sc_hd__decap_3
XFILLER_78_88 VGND VGND VPWR VPWR sky130_fd_sc_hd__decap_3
XFILLER_103_293 VGND VGND VPWR VPWR sky130_fd_sc_hd__decap_3
XFILLER_76_111 VGND VGND VPWR VPWR sky130_fd_sc_hd__fill_1
XFILLER_77_656 VGND VGND VPWR VPWR sky130_fd_sc_hd__decap_3
XFILLER_76_155 VGND VGND VPWR VPWR sky130_fd_sc_hd__decap_3
XFILLER_92_604 VGND VGND VPWR VPWR sky130_fd_sc_hd__decap_3
XFILLER_94_21 VGND VGND VPWR VPWR sky130_fd_sc_hd__decap_3
XFILLER_17_211 VGND VGND VPWR VPWR sky130_fd_sc_hd__decap_3
XFILLER_91_125 VGND VGND VPWR VPWR sky130_fd_sc_hd__decap_3
XFILLER_92_637 VGND VGND VPWR VPWR sky130_fd_sc_hd__decap_3
XFILLER_92_648 VGND VGND VPWR VPWR sky130_fd_sc_hd__decap_3
XFILLER_27_81 VGND VGND VPWR VPWR sky130_fd_sc_hd__decap_3
XFILLER_45_542 VGND VGND VPWR VPWR sky130_fd_sc_hd__decap_3
XFILLER_45_564 VGND VGND VPWR VPWR sky130_fd_sc_hd__decap_3
XFILLER_91_169 VGND VGND VPWR VPWR sky130_fd_sc_hd__decap_3
XFILLER_27_92 VGND VGND VPWR VPWR sky130_fd_sc_hd__decap_3
XFILLER_32_203 VGND VGND VPWR VPWR sky130_fd_sc_hd__decap_3
XFILLER_45_597 VGND VGND VPWR VPWR sky130_fd_sc_hd__decap_3
XTAP_TAPCELL_ROW_15_434 VGND VPWR sky130_fd_sc_hd__tapvpwrvgnd_1
XFILLER_13_461 VGND VGND VPWR VPWR sky130_fd_sc_hd__decap_3
XFILLER_60_567 VGND VGND VPWR VPWR sky130_fd_sc_hd__decap_3
XFILLER_60_589 VGND VGND VPWR VPWR sky130_fd_sc_hd__decap_3
XTAP_TAPCELL_ROW_43_765 VGND VPWR sky130_fd_sc_hd__tapvpwrvgnd_1
XFILLER_9_432 VGND VGND VPWR VPWR sky130_fd_sc_hd__decap_3
XFILLER_40_291 VGND VGND VPWR VPWR sky130_fd_sc_hd__fill_1
XFILLER_114_525 VGND VGND VPWR VPWR sky130_fd_sc_hd__decap_3
XFILLER_114_536 VGND VGND VPWR VPWR sky130_fd_sc_hd__decap_3
XFILLER_5_671 VGND VGND VPWR VPWR sky130_fd_sc_hd__fill_1
XFILLER_5_682 VGND VGND VPWR VPWR sky130_fd_sc_hd__decap_3
X_5280_ hold997/X _5121_/X _5292_/S VGND VGND VPWR VPWR _7190_/D sky130_fd_sc_hd__mux2_2
X_4300_ _7288_/Q _4300_/B VGND VGND VPWR VPWR _4300_/X sky130_fd_sc_hd__and2_2
XFILLER_99_225 VGND VGND VPWR VPWR sky130_fd_sc_hd__decap_3
XFILLER_114_569 VGND VGND VPWR VPWR sky130_fd_sc_hd__decap_3
XFILLER_4_170 VGND VGND VPWR VPWR sky130_fd_sc_hd__decap_3
X_4231_ _7040_/Q _4534_/S _4346_/B1 _7387_/Q _4230_/X VGND VGND VPWR VPWR _4231_/X
+ sky130_fd_sc_hd__a221o_2
XFILLER_101_208 VGND VGND VPWR VPWR sky130_fd_sc_hd__decap_3
XFILLER_4_85 VGND VGND VPWR VPWR sky130_fd_sc_hd__fill_1
XFILLER_68_601 VGND VGND VPWR VPWR sky130_fd_sc_hd__decap_3
XFILLER_68_634 VGND VGND VPWR VPWR sky130_fd_sc_hd__decap_3
XFILLER_68_645 VGND VGND VPWR VPWR sky130_fd_sc_hd__decap_3
XFILLER_95_442 VGND VGND VPWR VPWR sky130_fd_sc_hd__decap_3
X_4162_ _7137_/Q _4428_/B1 _4161_/X VGND VGND VPWR VPWR _4203_/A sky130_fd_sc_hd__a21o_2
XFILLER_28_509 VGND VGND VPWR VPWR sky130_fd_sc_hd__decap_3
XFILLER_67_166 VGND VGND VPWR VPWR sky130_fd_sc_hd__fill_2
XFILLER_68_678 VGND VGND VPWR VPWR sky130_fd_sc_hd__decap_3
XFILLER_83_615 VGND VGND VPWR VPWR sky130_fd_sc_hd__fill_1
X_4093_ _4394_/A _4093_/B _4092_/X VGND VGND VPWR VPWR _4210_/B sky130_fd_sc_hd__or3b_2
XFILLER_55_328 VGND VGND VPWR VPWR sky130_fd_sc_hd__decap_3
XFILLER_67_177 VGND VGND VPWR VPWR sky130_fd_sc_hd__decap_3
XFILLER_67_199 VGND VGND VPWR VPWR sky130_fd_sc_hd__decap_3
XFILLER_82_114 VGND VGND VPWR VPWR sky130_fd_sc_hd__decap_3
XFILLER_82_125 VGND VGND VPWR VPWR sky130_fd_sc_hd__decap_3
XFILLER_83_626 VGND VGND VPWR VPWR sky130_fd_sc_hd__decap_3
XFILLER_83_659 VGND VGND VPWR VPWR sky130_fd_sc_hd__decap_3
XFILLER_70_309 VGND VGND VPWR VPWR sky130_fd_sc_hd__decap_3
XFILLER_82_147 VGND VGND VPWR VPWR sky130_fd_sc_hd__decap_3
XFILLER_82_158 VGND VGND VPWR VPWR sky130_fd_sc_hd__decap_3
XFILLER_23_203 VGND VGND VPWR VPWR sky130_fd_sc_hd__decap_3
XFILLER_36_575 VGND VGND VPWR VPWR sky130_fd_sc_hd__decap_3
XFILLER_63_372 VGND VGND VPWR VPWR sky130_fd_sc_hd__fill_1
XFILLER_63_383 VGND VGND VPWR VPWR sky130_fd_sc_hd__decap_3
XFILLER_90_180 VGND VGND VPWR VPWR sky130_fd_sc_hd__decap_3
Xplace372 _3509_/B VGND VGND VPWR VPWR _4791_/C1 sky130_fd_sc_hd__buf_2
Xplace361 _5157_/S VGND VGND VPWR VPWR _5108_/S sky130_fd_sc_hd__buf_2
Xplace350 _4312_/B VGND VGND VPWR VPWR _4093_/B sky130_fd_sc_hd__buf_2
X_6803_ _7405_/CLK _6803_/D VGND VGND VPWR VPWR _6803_/Q sky130_fd_sc_hd__dfxtp_2
X_4995_ _4811_/C _4987_/Y _4993_/X _4994_/X VGND VGND VPWR VPWR _5657_/D sky130_fd_sc_hd__a211o_2
XFILLER_51_567 VGND VGND VPWR VPWR sky130_fd_sc_hd__decap_3
Xplace383 _4348_/B1 VGND VGND VPWR VPWR _4420_/B1 sky130_fd_sc_hd__buf_2
Xplace394 _5323_/S VGND VGND VPWR VPWR _5315_/S sky130_fd_sc_hd__buf_2
X_6734_ _6954_/CLK _6734_/D VGND VGND VPWR VPWR _6734_/Q sky130_fd_sc_hd__dfxtp_2
X_6665_ _6672_/A VGND VGND VPWR VPWR _6665_/Y sky130_fd_sc_hd__inv_2
X_3877_ _6906_/Q _3879_/A2 _3878_/A2 _6850_/Q _3876_/X VGND VGND VPWR VPWR _3877_/X
+ sky130_fd_sc_hd__a221o_2
X_6596_ _6596_/A VGND VGND VPWR VPWR _6596_/Y sky130_fd_sc_hd__inv_2
XFILLER_105_514 VGND VGND VPWR VPWR sky130_fd_sc_hd__decap_3
XFILLER_105_547 VGND VGND VPWR VPWR sky130_fd_sc_hd__decap_3
XFILLER_3_9 VGND VGND VPWR VPWR sky130_fd_sc_hd__decap_3
XFILLER_78_409 VGND VGND VPWR VPWR sky130_fd_sc_hd__fill_2
X_7217_ _7317_/CLK _7217_/D _6497_/Y VGND VGND VPWR VPWR _7217_/Q sky130_fd_sc_hd__dfrtp_2
X_4429_ _7303_/Q _4488_/S _4437_/B1 _7367_/Q _4429_/C1 VGND VGND VPWR VPWR _4429_/X
+ sky130_fd_sc_hd__a221o_2
XFILLER_59_612 VGND VGND VPWR VPWR sky130_fd_sc_hd__decap_3
XFILLER_59_623 VGND VGND VPWR VPWR sky130_fd_sc_hd__decap_3
XFILLER_113_591 VGND VGND VPWR VPWR sky130_fd_sc_hd__decap_3
XFILLER_48_47 VGND VGND VPWR VPWR sky130_fd_sc_hd__decap_3
XFILLER_59_656 VGND VGND VPWR VPWR sky130_fd_sc_hd__decap_3
X_7148_ _7307_/CLK _7148_/D _6428_/Y VGND VGND VPWR VPWR _7148_/Q sky130_fd_sc_hd__dfrtp_2
XFILLER_74_604 VGND VGND VPWR VPWR sky130_fd_sc_hd__decap_3
XFILLER_86_475 VGND VGND VPWR VPWR sky130_fd_sc_hd__fill_1
X_7079_ _7405_/CLK _7079_/D _6359_/Y VGND VGND VPWR VPWR _7079_/Q sky130_fd_sc_hd__dfrtp_2
XFILLER_73_103 VGND VGND VPWR VPWR sky130_fd_sc_hd__decap_3
XFILLER_74_637 VGND VGND VPWR VPWR sky130_fd_sc_hd__decap_3
XFILLER_74_648 VGND VGND VPWR VPWR sky130_fd_sc_hd__decap_3
XFILLER_100_296 VGND VGND VPWR VPWR sky130_fd_sc_hd__decap_3
XFILLER_27_553 VGND VGND VPWR VPWR sky130_fd_sc_hd__decap_3
XFILLER_64_35 VGND VGND VPWR VPWR sky130_fd_sc_hd__decap_3
XFILLER_73_147 VGND VGND VPWR VPWR sky130_fd_sc_hd__decap_3
XFILLER_14_203 VGND VGND VPWR VPWR sky130_fd_sc_hd__decap_3
XFILLER_27_564 VGND VGND VPWR VPWR sky130_fd_sc_hd__decap_3
XFILLER_42_501 VGND VGND VPWR VPWR sky130_fd_sc_hd__decap_3
XFILLER_64_79 VGND VGND VPWR VPWR sky130_fd_sc_hd__decap_3
XFILLER_73_169 VGND VGND VPWR VPWR sky130_fd_sc_hd__fill_1
XFILLER_82_681 VGND VGND VPWR VPWR sky130_fd_sc_hd__decap_3
XTAP_TAPCELL_ROW_64_1015 VGND VPWR sky130_fd_sc_hd__tapvpwrvgnd_1
XFILLER_27_597 VGND VGND VPWR VPWR sky130_fd_sc_hd__decap_3
XFILLER_42_523 VGND VGND VPWR VPWR sky130_fd_sc_hd__decap_3
XFILLER_42_545 VGND VGND VPWR VPWR sky130_fd_sc_hd__decap_3
XFILLER_54_383 VGND VGND VPWR VPWR sky130_fd_sc_hd__decap_3
XFILLER_42_578 VGND VGND VPWR VPWR sky130_fd_sc_hd__decap_3
XFILLER_42_589 VGND VGND VPWR VPWR sky130_fd_sc_hd__decap_3
Xfanout40 _6570_/A VGND VGND VPWR VPWR _6640_/A sky130_fd_sc_hd__clkdlybuf4s25_1
Xfanout51 _6683_/A VGND VGND VPWR VPWR _6364_/A sky130_fd_sc_hd__buf_2
Xfanout62 _6622_/A VGND VGND VPWR VPWR _6616_/A sky130_fd_sc_hd__buf_1
Xfanout73 fanout73/A VGND VGND VPWR VPWR _6288_/A sky130_fd_sc_hd__clkdlybuf4s25_1
XTAP_TAPCELL_ROW_40_735 VGND VPWR sky130_fd_sc_hd__tapvpwrvgnd_1
XFILLER_80_67 VGND VGND VPWR VPWR sky130_fd_sc_hd__decap_3
XFILLER_10_475 VGND VGND VPWR VPWR sky130_fd_sc_hd__fill_1
XFILLER_6_413 VGND VGND VPWR VPWR sky130_fd_sc_hd__decap_3
XFILLER_6_435 VGND VGND VPWR VPWR sky130_fd_sc_hd__decap_3
XFILLER_13_94 VGND VGND VPWR VPWR sky130_fd_sc_hd__fill_2
XFILLER_6_446 VGND VGND VPWR VPWR sky130_fd_sc_hd__decap_3
XTAP_TAPCELL_ROW_20_492 VGND VPWR sky130_fd_sc_hd__tapvpwrvgnd_1
XTAP_TAPCELL_ROW_75_1155 VGND VPWR sky130_fd_sc_hd__tapvpwrvgnd_1
XFILLER_111_517 VGND VGND VPWR VPWR sky130_fd_sc_hd__decap_3
XFILLER_2_663 VGND VGND VPWR VPWR sky130_fd_sc_hd__decap_3
XFILLER_1_195 VGND VGND VPWR VPWR sky130_fd_sc_hd__decap_3
XFILLER_65_615 VGND VGND VPWR VPWR sky130_fd_sc_hd__fill_1
XFILLER_37_328 VGND VGND VPWR VPWR sky130_fd_sc_hd__decap_3
XFILLER_64_103 VGND VGND VPWR VPWR sky130_fd_sc_hd__decap_3
XFILLER_65_626 VGND VGND VPWR VPWR sky130_fd_sc_hd__decap_3
XFILLER_77_486 VGND VGND VPWR VPWR sky130_fd_sc_hd__decap_3
XFILLER_92_412 VGND VGND VPWR VPWR sky130_fd_sc_hd__decap_3
XTAP_TAPCELL_ROW_48_824 VGND VPWR sky130_fd_sc_hd__tapvpwrvgnd_1
XFILLER_18_542 VGND VGND VPWR VPWR sky130_fd_sc_hd__decap_3
XFILLER_64_158 VGND VGND VPWR VPWR sky130_fd_sc_hd__decap_3
XFILLER_65_659 VGND VGND VPWR VPWR sky130_fd_sc_hd__decap_3
XFILLER_80_607 VGND VGND VPWR VPWR sky130_fd_sc_hd__decap_3
XFILLER_18_575 VGND VGND VPWR VPWR sky130_fd_sc_hd__decap_3
XFILLER_45_372 VGND VGND VPWR VPWR sky130_fd_sc_hd__decap_3
XFILLER_52_309 VGND VGND VPWR VPWR sky130_fd_sc_hd__decap_3
XFILLER_72_180 VGND VGND VPWR VPWR sky130_fd_sc_hd__decap_3
XTAP_TAPCELL_ROW_86_1284 VGND VPWR sky130_fd_sc_hd__tapvpwrvgnd_1
XTAP_TAPCELL_ROW_28_592 VGND VPWR sky130_fd_sc_hd__tapvpwrvgnd_1
XFILLER_33_556 VGND VGND VPWR VPWR sky130_fd_sc_hd__decap_3
XFILLER_33_567 VGND VGND VPWR VPWR sky130_fd_sc_hd__decap_3
XFILLER_60_342 VGND VGND VPWR VPWR sky130_fd_sc_hd__decap_3
X_4780_ _4779_/X _4447_/B _4795_/A VGND VGND VPWR VPWR _4780_/Y sky130_fd_sc_hd__a21oi_2
X_3800_ _6861_/Q _3879_/B1 _3892_/B1 _6901_/Q _3799_/X VGND VGND VPWR VPWR _3800_/X
+ sky130_fd_sc_hd__a221o_2
X_3731_ _6758_/Q _3903_/B1 _3883_/B1 _6770_/Q VGND VGND VPWR VPWR _3731_/X sky130_fd_sc_hd__a22o_2
XFILLER_9_251 VGND VGND VPWR VPWR sky130_fd_sc_hd__decap_3
Xclkload10 _6974_/CLK VGND VGND VPWR VPWR clkload10/X sky130_fd_sc_hd__clkbuf_1
X_6450_ _6643_/A VGND VGND VPWR VPWR _6450_/Y sky130_fd_sc_hd__inv_2
Xclkload21 _7398_/CLK VGND VGND VPWR VPWR clkload21/X sky130_fd_sc_hd__clkbuf_8
Xclkload32 _7392_/CLK VGND VGND VPWR VPWR clkload32/Y sky130_fd_sc_hd__clkinv_2
X_6381_ _6569_/A VGND VGND VPWR VPWR _6381_/Y sky130_fd_sc_hd__inv_2
X_3593_ _3620_/A _4292_/B _3592_/X VGND VGND VPWR VPWR _3594_/B sky130_fd_sc_hd__a21o_2
XFILLER_102_528 VGND VGND VPWR VPWR sky130_fd_sc_hd__decap_3
XFILLER_87_217 VGND VGND VPWR VPWR sky130_fd_sc_hd__decap_3
XFILLER_102_539 VGND VGND VPWR VPWR sky130_fd_sc_hd__decap_3
X_7002_ _7144_/CLK _7002_/D _6282_/Y VGND VGND VPWR VPWR _7002_/Q sky130_fd_sc_hd__dfrtp_2
X_5194_ _5194_/A _5209_/B VGND VGND VPWR VPWR _7231_/D sky130_fd_sc_hd__and2_2
X_4214_ _7228_/Q _4421_/A2 _4348_/A2 _7164_/Q _4213_/X VGND VGND VPWR VPWR _4214_/X
+ sky130_fd_sc_hd__a221o_2
XFILLER_28_306 VGND VGND VPWR VPWR sky130_fd_sc_hd__fill_2
XFILLER_56_604 VGND VGND VPWR VPWR sky130_fd_sc_hd__decap_3
XFILLER_95_250 VGND VGND VPWR VPWR sky130_fd_sc_hd__decap_3
X_4145_ _7298_/Q _4269_/B1 _4144_/X _4347_/C1 VGND VGND VPWR VPWR _4145_/X sky130_fd_sc_hd__a211o_2
XFILLER_110_572 VGND VGND VPWR VPWR sky130_fd_sc_hd__decap_3
XFILLER_56_637 VGND VGND VPWR VPWR sky130_fd_sc_hd__decap_3
XFILLER_56_648 VGND VGND VPWR VPWR sky130_fd_sc_hd__decap_3
XFILLER_68_497 VGND VGND VPWR VPWR sky130_fd_sc_hd__decap_3
XFILLER_83_412 VGND VGND VPWR VPWR sky130_fd_sc_hd__decap_3
XFILLER_83_434 VGND VGND VPWR VPWR sky130_fd_sc_hd__decap_3
X_4076_ _7147_/Q _4434_/B1 _4436_/B1 _7179_/Q VGND VGND VPWR VPWR _4076_/X sky130_fd_sc_hd__a22o_2
XFILLER_24_512 VGND VGND VPWR VPWR sky130_fd_sc_hd__decap_3
XFILLER_55_169 VGND VGND VPWR VPWR sky130_fd_sc_hd__fill_1
XFILLER_64_681 VGND VGND VPWR VPWR sky130_fd_sc_hd__decap_3
XFILLER_71_629 VGND VGND VPWR VPWR sky130_fd_sc_hd__decap_3
XFILLER_83_489 VGND VGND VPWR VPWR sky130_fd_sc_hd__decap_3
XFILLER_24_545 VGND VGND VPWR VPWR sky130_fd_sc_hd__decap_3
XFILLER_51_331 VGND VGND VPWR VPWR sky130_fd_sc_hd__decap_3
XFILLER_24_578 VGND VGND VPWR VPWR sky130_fd_sc_hd__decap_3
XFILLER_11_228 VGND VGND VPWR VPWR sky130_fd_sc_hd__decap_3
XFILLER_24_589 VGND VGND VPWR VPWR sky130_fd_sc_hd__decap_3
X_4978_ _5092_/C _4973_/X _4975_/Y _6993_/D _4997_/A1 VGND VGND VPWR VPWR _4978_/X
+ sky130_fd_sc_hd__a32o_2
Xclkload4 clkload4/A VGND VGND VPWR VPWR clkload4/X sky130_fd_sc_hd__clkbuf_16
X_6717_ _7403_/CLK _6717_/D VGND VGND VPWR VPWR _6717_/Q sky130_fd_sc_hd__dfxtp_2
XFILLER_50_26 VGND VGND VPWR VPWR sky130_fd_sc_hd__fill_2
X_6648_ _6654_/A VGND VGND VPWR VPWR _6648_/Y sky130_fd_sc_hd__inv_2
X_6579_ _6581_/A VGND VGND VPWR VPWR _6579_/Y sky130_fd_sc_hd__inv_2
XFILLER_105_322 VGND VGND VPWR VPWR sky130_fd_sc_hd__decap_3
XFILLER_1_6 VGND VGND VPWR VPWR sky130_fd_sc_hd__decap_3
XFILLER_3_449 VGND VGND VPWR VPWR sky130_fd_sc_hd__fill_1
XFILLER_59_57 VGND VGND VPWR VPWR sky130_fd_sc_hd__decap_3
XFILLER_78_206 VGND VGND VPWR VPWR sky130_fd_sc_hd__decap_3
XFILLER_115_30 VGND VGND VPWR VPWR sky130_fd_sc_hd__decap_3
XFILLER_101_550 VGND VGND VPWR VPWR sky130_fd_sc_hd__decap_3
XFILLER_115_63 VGND VGND VPWR VPWR sky130_fd_sc_hd__decap_3
XFILLER_101_561 VGND VGND VPWR VPWR sky130_fd_sc_hd__decap_3
XFILLER_101_594 VGND VGND VPWR VPWR sky130_fd_sc_hd__decap_3
XFILLER_115_96 VGND VGND VPWR VPWR sky130_fd_sc_hd__decap_3
XFILLER_47_615 VGND VGND VPWR VPWR sky130_fd_sc_hd__fill_1
XFILLER_47_626 VGND VGND VPWR VPWR sky130_fd_sc_hd__decap_3
XFILLER_59_475 VGND VGND VPWR VPWR sky130_fd_sc_hd__decap_3
XFILLER_86_283 VGND VGND VPWR VPWR sky130_fd_sc_hd__decap_3
XTAP_TAPCELL_ROW_70_1096 VGND VPWR sky130_fd_sc_hd__tapvpwrvgnd_1
XFILLER_46_147 VGND VGND VPWR VPWR sky130_fd_sc_hd__decap_3
XFILLER_47_659 VGND VGND VPWR VPWR sky130_fd_sc_hd__decap_3
XFILLER_62_607 VGND VGND VPWR VPWR sky130_fd_sc_hd__decap_3
XFILLER_86_294 VGND VGND VPWR VPWR sky130_fd_sc_hd__decap_3
XFILLER_34_309 VGND VGND VPWR VPWR sky130_fd_sc_hd__decap_3
XFILLER_61_106 VGND VGND VPWR VPWR sky130_fd_sc_hd__decap_3
XFILLER_15_523 VGND VGND VPWR VPWR sky130_fd_sc_hd__decap_3
XFILLER_42_331 VGND VGND VPWR VPWR sky130_fd_sc_hd__decap_3
XFILLER_70_640 VGND VGND VPWR VPWR sky130_fd_sc_hd__decap_3
XFILLER_15_556 VGND VGND VPWR VPWR sky130_fd_sc_hd__decap_3
XFILLER_15_567 VGND VGND VPWR VPWR sky130_fd_sc_hd__decap_3
XFILLER_70_651 VGND VGND VPWR VPWR sky130_fd_sc_hd__decap_3
XTAP_TAPCELL_ROW_25_551 VGND VPWR sky130_fd_sc_hd__tapvpwrvgnd_1
XFILLER_70_684 VGND VGND VPWR VPWR sky130_fd_sc_hd__decap_3
XTAP_TAPCELL_ROW_53_893 VGND VPWR sky130_fd_sc_hd__tapvpwrvgnd_1
XTAP_TAPCELL_ROW_53_882 VGND VPWR sky130_fd_sc_hd__tapvpwrvgnd_1
XFILLER_24_71 VGND VGND VPWR VPWR sky130_fd_sc_hd__decap_3
XFILLER_109_650 VGND VGND VPWR VPWR sky130_fd_sc_hd__decap_3
XFILLER_10_283 VGND VGND VPWR VPWR sky130_fd_sc_hd__decap_3
XFILLER_116_609 VGND VGND VPWR VPWR sky130_fd_sc_hd__decap_3
XFILLER_115_108 VGND VGND VPWR VPWR sky130_fd_sc_hd__decap_3
XFILLER_115_119 VGND VGND VPWR VPWR sky130_fd_sc_hd__decap_3
XFILLER_69_217 VGND VGND VPWR VPWR sky130_fd_sc_hd__decap_3
XFILLER_97_526 VGND VGND VPWR VPWR sky130_fd_sc_hd__decap_3
XFILLER_69_228 VGND VGND VPWR VPWR sky130_fd_sc_hd__decap_3
XFILLER_97_559 VGND VGND VPWR VPWR sky130_fd_sc_hd__fill_1
XFILLER_111_347 VGND VGND VPWR VPWR sky130_fd_sc_hd__decap_3
XFILLER_38_604 VGND VGND VPWR VPWR sky130_fd_sc_hd__decap_3
XFILLER_77_250 VGND VGND VPWR VPWR sky130_fd_sc_hd__decap_3
XFILLER_38_637 VGND VGND VPWR VPWR sky130_fd_sc_hd__decap_3
XTAP_TAPCELL_ROW_88_1313 VGND VPWR sky130_fd_sc_hd__tapvpwrvgnd_1
XTAP_TAPCELL_ROW_88_1302 VGND VPWR sky130_fd_sc_hd__tapvpwrvgnd_1
XFILLER_37_125 VGND VGND VPWR VPWR sky130_fd_sc_hd__fill_2
XFILLER_37_147 VGND VGND VPWR VPWR sky130_fd_sc_hd__decap_3
XFILLER_38_648 VGND VGND VPWR VPWR sky130_fd_sc_hd__decap_3
XFILLER_65_445 VGND VGND VPWR VPWR sky130_fd_sc_hd__decap_3
XFILLER_25_309 VGND VGND VPWR VPWR sky130_fd_sc_hd__decap_3
XFILLER_37_169 VGND VGND VPWR VPWR sky130_fd_sc_hd__decap_3
XFILLER_53_629 VGND VGND VPWR VPWR sky130_fd_sc_hd__decap_3
XFILLER_92_253 VGND VGND VPWR VPWR sky130_fd_sc_hd__decap_3
XFILLER_46_681 VGND VGND VPWR VPWR sky130_fd_sc_hd__decap_3
XFILLER_52_139 VGND VGND VPWR VPWR sky130_fd_sc_hd__fill_1
XFILLER_80_448 VGND VGND VPWR VPWR sky130_fd_sc_hd__decap_3
X_4901_ _4901_/A0 _4899_/X _4979_/S VGND VGND VPWR VPWR _7268_/D sky130_fd_sc_hd__mux2_2
XFILLER_61_662 VGND VGND VPWR VPWR sky130_fd_sc_hd__decap_3
XFILLER_61_673 VGND VGND VPWR VPWR sky130_fd_sc_hd__decap_3
X_4832_ _4832_/A _5657_/A VGND VGND VPWR VPWR _4832_/X sky130_fd_sc_hd__or2_2
XFILLER_21_559 VGND VGND VPWR VPWR sky130_fd_sc_hd__fill_1
X_4763_ _4762_/A _4762_/B _4948_/A VGND VGND VPWR VPWR _4763_/X sky130_fd_sc_hd__a21o_2
X_6502_ _6566_/A VGND VGND VPWR VPWR _6502_/Y sky130_fd_sc_hd__inv_2
X_4694_ _7008_/Q _4728_/A VGND VGND VPWR VPWR _4694_/Y sky130_fd_sc_hd__nor2_2
X_3714_ _3735_/A _3741_/B _3746_/C VGND VGND VPWR VPWR _3714_/X sky130_fd_sc_hd__and3_2
XTAP_TAPCELL_ROW_99_1442 VGND VPWR sky130_fd_sc_hd__tapvpwrvgnd_1
XFILLER_107_609 VGND VGND VPWR VPWR sky130_fd_sc_hd__decap_3
X_6433_ _6632_/A VGND VGND VPWR VPWR _6433_/Y sky130_fd_sc_hd__inv_2
XFILLER_106_108 VGND VGND VPWR VPWR sky130_fd_sc_hd__decap_3
X_3645_ hold976/X _3822_/A2 _4664_/B VGND VGND VPWR VPWR _7406_/D sky130_fd_sc_hd__a21o_2
XFILLER_115_620 VGND VGND VPWR VPWR sky130_fd_sc_hd__decap_3
XFILLER_115_653 VGND VGND VPWR VPWR sky130_fd_sc_hd__decap_3
X_6364_ _6364_/A VGND VGND VPWR VPWR _6364_/Y sky130_fd_sc_hd__inv_2
X_3576_ _7252_/Q _4599_/S _3377_/X _7220_/Q _3575_/X VGND VGND VPWR VPWR _3576_/Y
+ sky130_fd_sc_hd__a221oi_2
XFILLER_114_141 VGND VGND VPWR VPWR sky130_fd_sc_hd__decap_3
XFILLER_114_163 VGND VGND VPWR VPWR sky130_fd_sc_hd__fill_1
X_6295_ _6635_/A VGND VGND VPWR VPWR _6295_/Y sky130_fd_sc_hd__inv_2
X_5315_ _5315_/A0 _4878_/X _5315_/S VGND VGND VPWR VPWR _7173_/D sky130_fd_sc_hd__mux2_2
XFILLER_88_548 VGND VGND VPWR VPWR sky130_fd_sc_hd__decap_3
XPHY_EDGE_ROW_89_Right_89 VGND VGND VPWR VPWR sky130_fd_sc_hd__decap_3
XFILLER_29_615 VGND VGND VPWR VPWR sky130_fd_sc_hd__fill_1
XFILLER_29_626 VGND VGND VPWR VPWR sky130_fd_sc_hd__decap_3
XFILLER_56_401 VGND VGND VPWR VPWR sky130_fd_sc_hd__decap_3
XFILLER_68_272 VGND VGND VPWR VPWR sky130_fd_sc_hd__decap_3
XFILLER_96_581 VGND VGND VPWR VPWR sky130_fd_sc_hd__decap_3
XFILLER_96_592 VGND VGND VPWR VPWR sky130_fd_sc_hd__decap_3
X_5177_ _5177_/A _5177_/B VGND VGND VPWR VPWR _7239_/D sky130_fd_sc_hd__and2_2
XFILLER_28_147 VGND VGND VPWR VPWR sky130_fd_sc_hd__decap_3
XFILLER_29_659 VGND VGND VPWR VPWR sky130_fd_sc_hd__decap_3
XFILLER_56_456 VGND VGND VPWR VPWR sky130_fd_sc_hd__decap_3
XFILLER_83_220 VGND VGND VPWR VPWR sky130_fd_sc_hd__decap_3
X_4128_ _7331_/Q _3954_/S _4420_/B1 _7139_/Q VGND VGND VPWR VPWR _4128_/X sky130_fd_sc_hd__a22o_2
XFILLER_16_309 VGND VGND VPWR VPWR sky130_fd_sc_hd__fill_1
XFILLER_44_607 VGND VGND VPWR VPWR sky130_fd_sc_hd__decap_3
XFILLER_56_489 VGND VGND VPWR VPWR sky130_fd_sc_hd__fill_1
X_4059_ _7276_/Q _4437_/A2 _4056_/X _4058_/X VGND VGND VPWR VPWR _4059_/X sky130_fd_sc_hd__a211o_2
XFILLER_24_320 VGND VGND VPWR VPWR sky130_fd_sc_hd__decap_3
XFILLER_83_297 VGND VGND VPWR VPWR sky130_fd_sc_hd__decap_3
XFILLER_24_353 VGND VGND VPWR VPWR sky130_fd_sc_hd__decap_3
XFILLER_36_191 VGND VGND VPWR VPWR sky130_fd_sc_hd__decap_3
XFILLER_52_640 VGND VGND VPWR VPWR sky130_fd_sc_hd__decap_3
XFILLER_52_651 VGND VGND VPWR VPWR sky130_fd_sc_hd__decap_3
XFILLER_101_54 VGND VGND VPWR VPWR sky130_fd_sc_hd__fill_2
XFILLER_12_526 VGND VGND VPWR VPWR sky130_fd_sc_hd__decap_3
XFILLER_52_684 VGND VGND VPWR VPWR sky130_fd_sc_hd__decap_3
XTAP_TAPCELL_ROW_22_510 VGND VPWR sky130_fd_sc_hd__tapvpwrvgnd_1
XPHY_EDGE_ROW_98_Right_98 VGND VGND VPWR VPWR sky130_fd_sc_hd__decap_3
XFILLER_12_548 VGND VGND VPWR VPWR sky130_fd_sc_hd__decap_3
XFILLER_8_519 VGND VGND VPWR VPWR sky130_fd_sc_hd__decap_3
XTAP_TAPCELL_ROW_50_852 VGND VPWR sky130_fd_sc_hd__tapvpwrvgnd_1
XTAP_TAPCELL_ROW_22_521 VGND VPWR sky130_fd_sc_hd__tapvpwrvgnd_1
XFILLER_20_581 VGND VGND VPWR VPWR sky130_fd_sc_hd__decap_3
XFILLER_20_592 VGND VGND VPWR VPWR sky130_fd_sc_hd__decap_3
XFILLER_106_631 VGND VGND VPWR VPWR sky130_fd_sc_hd__decap_3
XFILLER_106_675 VGND VGND VPWR VPWR sky130_fd_sc_hd__decap_3
XFILLER_10_62 VGND VGND VPWR VPWR sky130_fd_sc_hd__decap_3
XTAP_TAPCELL_ROW_72_1114 VGND VPWR sky130_fd_sc_hd__tapvpwrvgnd_1
XPHY_EDGE_ROW_5_Left_122 VGND VGND VPWR VPWR sky130_fd_sc_hd__decap_3
XFILLER_79_548 VGND VGND VPWR VPWR sky130_fd_sc_hd__decap_3
XFILLER_86_11 VGND VGND VPWR VPWR sky130_fd_sc_hd__fill_1
XFILLER_66_209 VGND VGND VPWR VPWR sky130_fd_sc_hd__decap_3
XFILLER_87_570 VGND VGND VPWR VPWR sky130_fd_sc_hd__decap_3
XFILLER_94_529 VGND VGND VPWR VPWR sky130_fd_sc_hd__decap_3
XFILLER_101_380 VGND VGND VPWR VPWR sky130_fd_sc_hd__decap_3
XFILLER_101_391 VGND VGND VPWR VPWR sky130_fd_sc_hd__fill_1
XFILLER_86_99 VGND VGND VPWR VPWR sky130_fd_sc_hd__fill_2
XTAP_TAPCELL_ROW_58_952 VGND VPWR sky130_fd_sc_hd__tapvpwrvgnd_1
XFILLER_19_169 VGND VGND VPWR VPWR sky130_fd_sc_hd__decap_3
XFILLER_35_629 VGND VGND VPWR VPWR sky130_fd_sc_hd__decap_3
XFILLER_74_253 VGND VGND VPWR VPWR sky130_fd_sc_hd__decap_3
XFILLER_28_681 VGND VGND VPWR VPWR sky130_fd_sc_hd__decap_3
XFILLER_62_448 VGND VGND VPWR VPWR sky130_fd_sc_hd__decap_3
XFILLER_74_286 VGND VGND VPWR VPWR sky130_fd_sc_hd__decap_3
XFILLER_74_297 VGND VGND VPWR VPWR sky130_fd_sc_hd__decap_3
XFILLER_43_662 VGND VGND VPWR VPWR sky130_fd_sc_hd__decap_3
XTAP_TAPCELL_ROW_83_1243 VGND VPWR sky130_fd_sc_hd__tapvpwrvgnd_1
XFILLER_43_673 VGND VGND VPWR VPWR sky130_fd_sc_hd__decap_3
XFILLER_30_323 VGND VGND VPWR VPWR sky130_fd_sc_hd__decap_3
XFILLER_11_570 VGND VGND VPWR VPWR sky130_fd_sc_hd__decap_3
XFILLER_7_541 VGND VGND VPWR VPWR sky130_fd_sc_hd__decap_3
XFILLER_116_417 VGND VGND VPWR VPWR sky130_fd_sc_hd__decap_3
XFILLER_7_585 VGND VGND VPWR VPWR sky130_fd_sc_hd__decap_3
XFILLER_109_491 VGND VGND VPWR VPWR sky130_fd_sc_hd__decap_3
XFILLER_116_439 VGND VGND VPWR VPWR sky130_fd_sc_hd__decap_3
XFILLER_112_601 VGND VGND VPWR VPWR sky130_fd_sc_hd__decap_3
X_3361_ _3561_/A _3386_/B VGND VGND VPWR VPWR _3376_/B sky130_fd_sc_hd__and2_2
XTAP_TAPCELL_ROW_94_1383 VGND VPWR sky130_fd_sc_hd__tapvpwrvgnd_1
XFILLER_111_111 VGND VGND VPWR VPWR sky130_fd_sc_hd__fill_1
XFILLER_112_634 VGND VGND VPWR VPWR sky130_fd_sc_hd__decap_3
XFILLER_32_3 VGND VGND VPWR VPWR sky130_fd_sc_hd__decap_3
XFILLER_97_334 VGND VGND VPWR VPWR sky130_fd_sc_hd__fill_2
X_5100_ _5100_/A _5100_/B VGND VGND VPWR VPWR _5100_/Y sky130_fd_sc_hd__xnor2_2
XFILLER_112_645 VGND VGND VPWR VPWR sky130_fd_sc_hd__decap_3
XFILLER_112_678 VGND VGND VPWR VPWR sky130_fd_sc_hd__decap_3
X_5031_ _5032_/A _5031_/B VGND VGND VPWR VPWR _5031_/X sky130_fd_sc_hd__xor2_2
XFILLER_111_166 VGND VGND VPWR VPWR sky130_fd_sc_hd__fill_2
XFILLER_78_581 VGND VGND VPWR VPWR sky130_fd_sc_hd__decap_3
XFILLER_85_518 VGND VGND VPWR VPWR sky130_fd_sc_hd__decap_3
Xhold1208 _7176_/Q VGND VGND VPWR VPWR _5308_/A0 sky130_fd_sc_hd__dlygate4sd3_1
Xhold1219 _7396_/Q VGND VGND VPWR VPWR _3757_/A0 sky130_fd_sc_hd__dlygate4sd3_1
XFILLER_38_445 VGND VGND VPWR VPWR sky130_fd_sc_hd__decap_3
XFILLER_65_231 VGND VGND VPWR VPWR sky130_fd_sc_hd__decap_3
XFILLER_78_592 VGND VGND VPWR VPWR sky130_fd_sc_hd__decap_3
XFILLER_26_607 VGND VGND VPWR VPWR sky130_fd_sc_hd__decap_3
XFILLER_65_253 VGND VGND VPWR VPWR sky130_fd_sc_hd__fill_2
XFILLER_93_573 VGND VGND VPWR VPWR sky130_fd_sc_hd__decap_3
XPHY_EDGE_ROW_69_Left_186 VGND VGND VPWR VPWR sky130_fd_sc_hd__decap_3
X_6982_ clkload7/A _6982_/D _6262_/Y VGND VGND VPWR VPWR _6982_/Q sky130_fd_sc_hd__dfrtp_2
XTAP_TAPCELL_ROW_0_249 VGND VPWR sky130_fd_sc_hd__tapvpwrvgnd_1
XTAP_TAPCELL_ROW_0_238 VGND VPWR sky130_fd_sc_hd__tapvpwrvgnd_1
XFILLER_34_640 VGND VGND VPWR VPWR sky130_fd_sc_hd__decap_3
XFILLER_34_651 VGND VGND VPWR VPWR sky130_fd_sc_hd__decap_3
XFILLER_80_245 VGND VGND VPWR VPWR sky130_fd_sc_hd__decap_3
XFILLER_80_256 VGND VGND VPWR VPWR sky130_fd_sc_hd__decap_3
XFILLER_80_267 VGND VGND VPWR VPWR sky130_fd_sc_hd__decap_3
XFILLER_34_684 VGND VGND VPWR VPWR sky130_fd_sc_hd__decap_3
XFILLER_80_289 VGND VGND VPWR VPWR sky130_fd_sc_hd__decap_3
XTAP_TAPCELL_ROW_36_679 VGND VPWR sky130_fd_sc_hd__tapvpwrvgnd_1
X_4815_ _4812_/Y _4813_/Y _4814_/Y _4779_/X VGND VGND VPWR VPWR _4815_/X sky130_fd_sc_hd__o211a_2
XFILLER_21_389 VGND VGND VPWR VPWR sky130_fd_sc_hd__decap_3
XTAP_TAPCELL_ROW_103_1490 VGND VPWR sky130_fd_sc_hd__tapvpwrvgnd_1
X_4746_ _4764_/B _4069_/B _4744_/Y _4745_/Y _4852_/A VGND VGND VPWR VPWR _4746_/X
+ sky130_fd_sc_hd__o32a_2
X_4677_ _6989_/Q _4677_/B VGND VGND VPWR VPWR _5036_/A sky130_fd_sc_hd__and2_2
XPHY_EDGE_ROW_78_Left_195 VGND VGND VPWR VPWR sky130_fd_sc_hd__decap_3
XFILLER_103_9 VGND VGND VPWR VPWR sky130_fd_sc_hd__decap_3
X_7396_ _7404_/CLK _7396_/D _6676_/Y VGND VGND VPWR VPWR _7396_/Q sky130_fd_sc_hd__dfrtp_2
X_6416_ _6637_/A VGND VGND VPWR VPWR _6416_/Y sky130_fd_sc_hd__inv_2
XFILLER_115_461 VGND VGND VPWR VPWR sky130_fd_sc_hd__decap_3
X_6347_ _6663_/A VGND VGND VPWR VPWR _6347_/Y sky130_fd_sc_hd__inv_2
XFILLER_0_216 VGND VGND VPWR VPWR sky130_fd_sc_hd__decap_3
XFILLER_103_612 VGND VGND VPWR VPWR sky130_fd_sc_hd__decap_3
XFILLER_103_623 VGND VGND VPWR VPWR sky130_fd_sc_hd__decap_3
XFILLER_115_494 VGND VGND VPWR VPWR sky130_fd_sc_hd__decap_3
X_3559_ _3553_/X _3557_/X _3558_/X _3590_/A VGND VGND VPWR VPWR _4295_/B sky130_fd_sc_hd__o211a_2
XTAP_TAPCELL_ROW_8_349 VGND VPWR sky130_fd_sc_hd__tapvpwrvgnd_1
XFILLER_0_238 VGND VGND VPWR VPWR sky130_fd_sc_hd__decap_3
XFILLER_102_133 VGND VGND VPWR VPWR sky130_fd_sc_hd__decap_3
XFILLER_103_656 VGND VGND VPWR VPWR sky130_fd_sc_hd__decap_3
XFILLER_88_345 VGND VGND VPWR VPWR sky130_fd_sc_hd__decap_3
X_6278_ _6278_/A VGND VGND VPWR VPWR _6278_/Y sky130_fd_sc_hd__inv_2
XFILLER_102_155 VGND VGND VPWR VPWR sky130_fd_sc_hd__fill_1
XFILLER_29_401 VGND VGND VPWR VPWR sky130_fd_sc_hd__decap_3
XFILLER_48_209 VGND VGND VPWR VPWR sky130_fd_sc_hd__decap_3
XFILLER_69_570 VGND VGND VPWR VPWR sky130_fd_sc_hd__decap_3
X_5229_ _5362_/C _5229_/B _5229_/C VGND VGND VPWR VPWR _5292_/S sky130_fd_sc_hd__and3b_2
XFILLER_56_220 VGND VGND VPWR VPWR sky130_fd_sc_hd__decap_3
XFILLER_17_629 VGND VGND VPWR VPWR sky130_fd_sc_hd__decap_3
XFILLER_29_478 VGND VGND VPWR VPWR sky130_fd_sc_hd__decap_3
XFILLER_56_242 VGND VGND VPWR VPWR sky130_fd_sc_hd__fill_2
XFILLER_56_253 VGND VGND VPWR VPWR sky130_fd_sc_hd__decap_3
XFILLER_84_551 VGND VGND VPWR VPWR sky130_fd_sc_hd__decap_3
XTAP_TAPCELL_ROW_55_911 VGND VPWR sky130_fd_sc_hd__tapvpwrvgnd_1
XFILLER_16_139 VGND VGND VPWR VPWR sky130_fd_sc_hd__fill_1
XFILLER_44_437 VGND VGND VPWR VPWR sky130_fd_sc_hd__fill_2
XFILLER_44_448 VGND VGND VPWR VPWR sky130_fd_sc_hd__decap_3
XFILLER_56_297 VGND VGND VPWR VPWR sky130_fd_sc_hd__decap_3
XFILLER_71_201 VGND VGND VPWR VPWR sky130_fd_sc_hd__fill_1
XFILLER_84_584 VGND VGND VPWR VPWR sky130_fd_sc_hd__decap_3
XFILLER_84_595 VGND VGND VPWR VPWR sky130_fd_sc_hd__decap_3
XTAP_TAPCELL_ROW_106_1519 VGND VPWR sky130_fd_sc_hd__tapvpwrvgnd_1
XFILLER_112_53 VGND VGND VPWR VPWR sky130_fd_sc_hd__decap_3
XFILLER_25_662 VGND VGND VPWR VPWR sky130_fd_sc_hd__decap_3
XFILLER_71_234 VGND VGND VPWR VPWR sky130_fd_sc_hd__decap_3
XFILLER_71_256 VGND VGND VPWR VPWR sky130_fd_sc_hd__decap_3
XFILLER_12_312 VGND VGND VPWR VPWR sky130_fd_sc_hd__decap_3
XFILLER_24_150 VGND VGND VPWR VPWR sky130_fd_sc_hd__decap_3
XFILLER_25_673 VGND VGND VPWR VPWR sky130_fd_sc_hd__decap_3
XFILLER_40_610 VGND VGND VPWR VPWR sky130_fd_sc_hd__decap_3
XFILLER_72_35 VGND VGND VPWR VPWR sky130_fd_sc_hd__decap_3
XFILLER_40_643 VGND VGND VPWR VPWR sky130_fd_sc_hd__fill_1
XFILLER_40_654 VGND VGND VPWR VPWR sky130_fd_sc_hd__decap_3
XFILLER_40_687 VGND VGND VPWR VPWR sky130_fd_sc_hd__decap_3
XFILLER_4_522 VGND VGND VPWR VPWR sky130_fd_sc_hd__decap_3
XFILLER_4_533 VGND VGND VPWR VPWR sky130_fd_sc_hd__decap_3
XFILLER_21_83 VGND VGND VPWR VPWR sky130_fd_sc_hd__decap_3
XFILLER_4_566 VGND VGND VPWR VPWR sky130_fd_sc_hd__decap_3
XFILLER_106_472 VGND VGND VPWR VPWR sky130_fd_sc_hd__decap_3
XFILLER_106_483 VGND VGND VPWR VPWR sky130_fd_sc_hd__decap_3
XFILLER_79_323 VGND VGND VPWR VPWR sky130_fd_sc_hd__decap_3
XFILLER_97_54 VGND VGND VPWR VPWR sky130_fd_sc_hd__fill_2
XFILLER_47_242 VGND VGND VPWR VPWR sky130_fd_sc_hd__fill_2
XFILLER_75_573 VGND VGND VPWR VPWR sky130_fd_sc_hd__decap_3
XFILLER_35_415 VGND VGND VPWR VPWR sky130_fd_sc_hd__decap_3
XFILLER_35_426 VGND VGND VPWR VPWR sky130_fd_sc_hd__decap_3
XFILLER_47_275 VGND VGND VPWR VPWR sky130_fd_sc_hd__decap_3
XFILLER_62_212 VGND VGND VPWR VPWR sky130_fd_sc_hd__decap_3
XFILLER_90_510 VGND VGND VPWR VPWR sky130_fd_sc_hd__fill_1
XFILLER_16_640 VGND VGND VPWR VPWR sky130_fd_sc_hd__decap_3
XFILLER_16_651 VGND VGND VPWR VPWR sky130_fd_sc_hd__decap_3
XFILLER_90_554 VGND VGND VPWR VPWR sky130_fd_sc_hd__decap_3
XFILLER_16_684 VGND VGND VPWR VPWR sky130_fd_sc_hd__decap_3
XFILLER_62_267 VGND VGND VPWR VPWR sky130_fd_sc_hd__fill_2
XFILLER_90_587 VGND VGND VPWR VPWR sky130_fd_sc_hd__fill_1
XFILLER_90_598 VGND VGND VPWR VPWR sky130_fd_sc_hd__decap_3
XFILLER_15_172 VGND VGND VPWR VPWR sky130_fd_sc_hd__decap_3
XFILLER_15_194 VGND VGND VPWR VPWR sky130_fd_sc_hd__decap_3
XFILLER_31_632 VGND VGND VPWR VPWR sky130_fd_sc_hd__decap_3
XTAP_TAPCELL_ROW_33_649 VGND VPWR sky130_fd_sc_hd__tapvpwrvgnd_1
XFILLER_31_665 VGND VGND VPWR VPWR sky130_fd_sc_hd__decap_3
XFILLER_31_676 VGND VGND VPWR VPWR sky130_fd_sc_hd__decap_3
XFILLER_30_197 VGND VGND VPWR VPWR sky130_fd_sc_hd__decap_3
XTAP_TAPCELL_ROW_96_1401 VGND VPWR sky130_fd_sc_hd__tapvpwrvgnd_1
XFILLER_7_360 VGND VGND VPWR VPWR sky130_fd_sc_hd__decap_3
XFILLER_116_225 VGND VGND VPWR VPWR sky130_fd_sc_hd__fill_2
X_7250_ _7353_/CLK _7250_/D _6530_/Y VGND VGND VPWR VPWR _7250_/Q sky130_fd_sc_hd__dfrtp_2
X_4462_ _3621_/B _3618_/X _3541_/X VGND VGND VPWR VPWR _4462_/Y sky130_fd_sc_hd__o21ai_2
XFILLER_116_247 VGND VGND VPWR VPWR sky130_fd_sc_hd__decap_3
XFILLER_89_109 VGND VGND VPWR VPWR sky130_fd_sc_hd__decap_3
X_3413_ _7155_/Q _3409_/X _3410_/X _3412_/X VGND VGND VPWR VPWR _3413_/X sky130_fd_sc_hd__a211o_2
X_7181_ _7372_/CLK _7181_/D _6461_/Y VGND VGND VPWR VPWR _7181_/Q sky130_fd_sc_hd__dfrtp_2
X_4393_ _7305_/Q _4946_/S _4434_/A2 _7113_/Q _4392_/X VGND VGND VPWR VPWR _4393_/X
+ sky130_fd_sc_hd__a221o_2
XFILLER_98_610 VGND VGND VPWR VPWR sky130_fd_sc_hd__decap_3
XFILLER_112_442 VGND VGND VPWR VPWR sky130_fd_sc_hd__decap_3
X_3344_ _3519_/B _5118_/D VGND VGND VPWR VPWR _3344_/Y sky130_fd_sc_hd__nor2_2
XTAP_TAPCELL_ROW_5_308 VGND VPWR sky130_fd_sc_hd__tapvpwrvgnd_1
XFILLER_98_654 VGND VGND VPWR VPWR sky130_fd_sc_hd__decap_3
XFILLER_98_643 VGND VGND VPWR VPWR sky130_fd_sc_hd__fill_1
XFILLER_100_604 VGND VGND VPWR VPWR sky130_fd_sc_hd__decap_3
XFILLER_112_475 VGND VGND VPWR VPWR sky130_fd_sc_hd__fill_1
XFILLER_112_486 VGND VGND VPWR VPWR sky130_fd_sc_hd__decap_3
XFILLER_85_304 VGND VGND VPWR VPWR sky130_fd_sc_hd__fill_2
XFILLER_85_315 VGND VGND VPWR VPWR sky130_fd_sc_hd__decap_3
XFILLER_97_153 VGND VGND VPWR VPWR sky130_fd_sc_hd__decap_3
Xhold1005 _7270_/Q VGND VGND VPWR VPWR _4865_/A0 sky130_fd_sc_hd__dlygate4sd3_1
XFILLER_98_687 VGND VGND VPWR VPWR sky130_fd_sc_hd__decap_3
XFILLER_100_637 VGND VGND VPWR VPWR sky130_fd_sc_hd__decap_3
XFILLER_100_648 VGND VGND VPWR VPWR sky130_fd_sc_hd__decap_3
XFILLER_38_220 VGND VGND VPWR VPWR sky130_fd_sc_hd__fill_2
XFILLER_85_337 VGND VGND VPWR VPWR sky130_fd_sc_hd__decap_3
Xhold1016 _7268_/Q VGND VGND VPWR VPWR _4901_/A0 sky130_fd_sc_hd__dlygate4sd3_1
Xhold1027 _7203_/Q VGND VGND VPWR VPWR _5253_/A0 sky130_fd_sc_hd__dlygate4sd3_1
Xhold1038 _7213_/Q VGND VGND VPWR VPWR _5234_/A0 sky130_fd_sc_hd__dlygate4sd3_1
Xhold1049 _7226_/Q VGND VGND VPWR VPWR _5205_/A sky130_fd_sc_hd__dlygate4sd3_1
X_5014_ _6990_/Q _5014_/B VGND VGND VPWR VPWR _5015_/C sky130_fd_sc_hd__or2_2
XFILLER_26_404 VGND VGND VPWR VPWR sky130_fd_sc_hd__fill_1
XFILLER_38_264 VGND VGND VPWR VPWR sky130_fd_sc_hd__decap_3
XFILLER_38_297 VGND VGND VPWR VPWR sky130_fd_sc_hd__decap_3
XFILLER_66_584 VGND VGND VPWR VPWR sky130_fd_sc_hd__decap_3
XFILLER_66_595 VGND VGND VPWR VPWR sky130_fd_sc_hd__decap_3
XFILLER_26_448 VGND VGND VPWR VPWR sky130_fd_sc_hd__decap_3
XFILLER_81_554 VGND VGND VPWR VPWR sky130_fd_sc_hd__decap_3
X_6965_ _6965_/CLK _6965_/D VGND VGND VPWR VPWR _6965_/Q sky130_fd_sc_hd__dfxtp_2
XFILLER_22_610 VGND VGND VPWR VPWR sky130_fd_sc_hd__decap_3
XFILLER_53_267 VGND VGND VPWR VPWR sky130_fd_sc_hd__decap_3
XFILLER_81_576 VGND VGND VPWR VPWR sky130_fd_sc_hd__decap_3
XFILLER_22_643 VGND VGND VPWR VPWR sky130_fd_sc_hd__fill_1
XFILLER_34_492 VGND VGND VPWR VPWR sky130_fd_sc_hd__decap_3
X_6896_ _6965_/CLK _6896_/D VGND VGND VPWR VPWR _6896_/Q sky130_fd_sc_hd__dfxtp_2
XFILLER_21_142 VGND VGND VPWR VPWR sky130_fd_sc_hd__decap_3
XFILLER_22_654 VGND VGND VPWR VPWR sky130_fd_sc_hd__decap_3
XFILLER_22_687 VGND VGND VPWR VPWR sky130_fd_sc_hd__decap_3
XPHY_EDGE_ROW_86_Left_203 VGND VGND VPWR VPWR sky130_fd_sc_hd__decap_3
X_4729_ _5040_/S _4729_/B VGND VGND VPWR VPWR _4729_/Y sky130_fd_sc_hd__nand2_2
XFILLER_101_6 VGND VGND VPWR VPWR sky130_fd_sc_hd__decap_3
XFILLER_1_514 VGND VGND VPWR VPWR sky130_fd_sc_hd__decap_3
XFILLER_89_632 VGND VGND VPWR VPWR sky130_fd_sc_hd__decap_3
X_7379_ clkload7/A _7379_/D _6659_/Y VGND VGND VPWR VPWR _7379_/Q sky130_fd_sc_hd__dfrtp_2
Xhold850 _7074_/Q VGND VGND VPWR VPWR _7074_/D sky130_fd_sc_hd__dlygate4sd3_1
Xhold861 _7084_/Q VGND VGND VPWR VPWR _7084_/D sky130_fd_sc_hd__dlygate4sd3_1
Xhold872 _7114_/Q VGND VGND VPWR VPWR _7114_/D sky130_fd_sc_hd__dlygate4sd3_1
XFILLER_107_42 VGND VGND VPWR VPWR sky130_fd_sc_hd__decap_3
XFILLER_107_64 VGND VGND VPWR VPWR sky130_fd_sc_hd__decap_3
XFILLER_1_547 VGND VGND VPWR VPWR sky130_fd_sc_hd__decap_3
XFILLER_89_665 VGND VGND VPWR VPWR sky130_fd_sc_hd__decap_3
Xhold883 _7102_/Q VGND VGND VPWR VPWR _7102_/D sky130_fd_sc_hd__dlygate4sd3_1
Xhold894 _7088_/Q VGND VGND VPWR VPWR _7088_/D sky130_fd_sc_hd__dlygate4sd3_1
XFILLER_103_453 VGND VGND VPWR VPWR sky130_fd_sc_hd__decap_3
XFILLER_103_486 VGND VGND VPWR VPWR sky130_fd_sc_hd__decap_3
XFILLER_107_97 VGND VGND VPWR VPWR sky130_fd_sc_hd__fill_2
XFILLER_67_57 VGND VGND VPWR VPWR sky130_fd_sc_hd__fill_2
XFILLER_89_676 VGND VGND VPWR VPWR sky130_fd_sc_hd__decap_3
XPHY_EDGE_ROW_95_Left_212 VGND VGND VPWR VPWR sky130_fd_sc_hd__decap_3
XFILLER_88_197 VGND VGND VPWR VPWR sky130_fd_sc_hd__decap_3
XFILLER_29_231 VGND VGND VPWR VPWR sky130_fd_sc_hd__fill_2
XFILLER_29_264 VGND VGND VPWR VPWR sky130_fd_sc_hd__decap_3
XFILLER_57_573 VGND VGND VPWR VPWR sky130_fd_sc_hd__decap_3
XFILLER_17_437 VGND VGND VPWR VPWR sky130_fd_sc_hd__fill_2
XFILLER_17_459 VGND VGND VPWR VPWR sky130_fd_sc_hd__fill_1
XFILLER_72_565 VGND VGND VPWR VPWR sky130_fd_sc_hd__decap_3
XFILLER_84_392 VGND VGND VPWR VPWR sky130_fd_sc_hd__decap_3
XTAP_TAPCELL_ROW_67_1057 VGND VPWR sky130_fd_sc_hd__tapvpwrvgnd_1
XFILLER_72_598 VGND VGND VPWR VPWR sky130_fd_sc_hd__decap_3
XFILLER_12_120 VGND VGND VPWR VPWR sky130_fd_sc_hd__decap_3
XFILLER_13_632 VGND VGND VPWR VPWR sky130_fd_sc_hd__decap_3
XFILLER_16_83 VGND VGND VPWR VPWR sky130_fd_sc_hd__fill_1
XTAP_TAPCELL_ROW_80_1213 VGND VPWR sky130_fd_sc_hd__tapvpwrvgnd_1
XFILLER_13_665 VGND VGND VPWR VPWR sky130_fd_sc_hd__decap_3
XFILLER_13_676 VGND VGND VPWR VPWR sky130_fd_sc_hd__decap_3
XTAP_TAPCELL_ROW_30_608 VGND VPWR sky130_fd_sc_hd__tapvpwrvgnd_1
XFILLER_9_603 VGND VGND VPWR VPWR sky130_fd_sc_hd__decap_3
XFILLER_40_495 VGND VGND VPWR VPWR sky130_fd_sc_hd__fill_2
XFILLER_9_647 VGND VGND VPWR VPWR sky130_fd_sc_hd__decap_3
XFILLER_12_197 VGND VGND VPWR VPWR sky130_fd_sc_hd__decap_3
XFILLER_32_60 VGND VGND VPWR VPWR sky130_fd_sc_hd__decap_3
XFILLER_66_9 VGND VGND VPWR VPWR sky130_fd_sc_hd__decap_3
XTAP_TAPCELL_ROW_10_376 VGND VPWR sky130_fd_sc_hd__tapvpwrvgnd_1
XTAP_TAPCELL_ROW_78_1186 VGND VPWR sky130_fd_sc_hd__tapvpwrvgnd_1
XFILLER_113_217 VGND VGND VPWR VPWR sky130_fd_sc_hd__fill_2
XFILLER_4_363 VGND VGND VPWR VPWR sky130_fd_sc_hd__fill_1
XFILLER_79_142 VGND VGND VPWR VPWR sky130_fd_sc_hd__decap_3
XTAP_TAPCELL_ROW_91_1342 VGND VPWR sky130_fd_sc_hd__tapvpwrvgnd_1
XFILLER_79_175 VGND VGND VPWR VPWR sky130_fd_sc_hd__decap_3
XFILLER_67_348 VGND VGND VPWR VPWR sky130_fd_sc_hd__decap_3
XFILLER_95_635 VGND VGND VPWR VPWR sky130_fd_sc_hd__decap_3
XFILLER_82_318 VGND VGND VPWR VPWR sky130_fd_sc_hd__decap_3
XFILLER_95_668 VGND VGND VPWR VPWR sky130_fd_sc_hd__decap_3
XFILLER_95_679 VGND VGND VPWR VPWR sky130_fd_sc_hd__decap_3
XTAP_TAPCELL_ROW_38_708 VGND VPWR sky130_fd_sc_hd__tapvpwrvgnd_1
XFILLER_48_573 VGND VGND VPWR VPWR sky130_fd_sc_hd__decap_3
XFILLER_48_595 VGND VGND VPWR VPWR sky130_fd_sc_hd__decap_3
XFILLER_63_554 VGND VGND VPWR VPWR sky130_fd_sc_hd__decap_3
XFILLER_63_576 VGND VGND VPWR VPWR sky130_fd_sc_hd__decap_3
XFILLER_90_362 VGND VGND VPWR VPWR sky130_fd_sc_hd__fill_2
X_6750_ _6978_/CLK _6750_/D VGND VGND VPWR VPWR _6750_/Q sky130_fd_sc_hd__dfxtp_2
XTAP_TAPCELL_ROW_18_465 VGND VPWR sky130_fd_sc_hd__tapvpwrvgnd_1
XFILLER_90_395 VGND VGND VPWR VPWR sky130_fd_sc_hd__decap_3
X_5701_ _7356_/Q hold936/X _5708_/S VGND VGND VPWR VPWR _6700_/D sky130_fd_sc_hd__mux2_2
X_3962_ _7359_/Q _4505_/A0 _3964_/S VGND VGND VPWR VPWR _7359_/D sky130_fd_sc_hd__mux2_2
XFILLER_50_259 VGND VGND VPWR VPWR sky130_fd_sc_hd__decap_3
X_6681_ _6685_/A VGND VGND VPWR VPWR _6681_/Y sky130_fd_sc_hd__inv_2
X_3893_ _6759_/Q _3651_/Y _3893_/B1 _6753_/Q _3892_/X VGND VGND VPWR VPWR _3893_/X
+ sky130_fd_sc_hd__a221o_2
X_5632_ _5632_/A VGND VGND VPWR VPWR _5633_/A sky130_fd_sc_hd__inv_2
X_5563_ hold952/X _4960_/A _4729_/B VGND VGND VPWR VPWR _7053_/D sky130_fd_sc_hd__a21bo_2
X_7302_ _7365_/CLK _7302_/D _6582_/Y VGND VGND VPWR VPWR _7302_/Q sky130_fd_sc_hd__dfrtp_2
XFILLER_104_206 VGND VGND VPWR VPWR sky130_fd_sc_hd__fill_1
XFILLER_104_228 VGND VGND VPWR VPWR sky130_fd_sc_hd__decap_3
X_7233_ _7332_/CLK _7233_/D _6513_/Y VGND VGND VPWR VPWR _7233_/Q sky130_fd_sc_hd__dfrtp_2
X_4445_ _4813_/A _4813_/B VGND VGND VPWR VPWR _4814_/B sky130_fd_sc_hd__nor2_2
X_7164_ _7364_/CLK _7164_/D _6444_/Y VGND VGND VPWR VPWR _7164_/Q sky130_fd_sc_hd__dfrtp_2
X_4376_ _4376_/A _4376_/B _4376_/C _4273_/D VGND VGND VPWR VPWR _4376_/X sky130_fd_sc_hd__or4b_2
XFILLER_86_613 VGND VGND VPWR VPWR sky130_fd_sc_hd__decap_3
X_3327_ _6981_/Q _6980_/Q VGND VGND VPWR VPWR _3328_/B sky130_fd_sc_hd__nor2_2
XFILLER_100_412 VGND VGND VPWR VPWR sky130_fd_sc_hd__decap_3
XFILLER_86_657 VGND VGND VPWR VPWR sky130_fd_sc_hd__decap_3
X_7095_ _7355_/CLK _7095_/D _6375_/Y VGND VGND VPWR VPWR _7095_/Q sky130_fd_sc_hd__dfrtp_2
XFILLER_98_495 VGND VGND VPWR VPWR sky130_fd_sc_hd__decap_3
XFILLER_100_467 VGND VGND VPWR VPWR sky130_fd_sc_hd__decap_3
XFILLER_37_38 VGND VGND VPWR VPWR sky130_fd_sc_hd__fill_1
XFILLER_100_489 VGND VGND VPWR VPWR sky130_fd_sc_hd__decap_3
XFILLER_39_573 VGND VGND VPWR VPWR sky130_fd_sc_hd__decap_3
XFILLER_73_318 VGND VGND VPWR VPWR sky130_fd_sc_hd__decap_3
XFILLER_94_690 VGND VGND VPWR VPWR sky130_fd_sc_hd__fill_1
XFILLER_26_245 VGND VGND VPWR VPWR sky130_fd_sc_hd__decap_3
XFILLER_14_407 VGND VGND VPWR VPWR sky130_fd_sc_hd__decap_3
XFILLER_26_256 VGND VGND VPWR VPWR sky130_fd_sc_hd__decap_3
XFILLER_26_278 VGND VGND VPWR VPWR sky130_fd_sc_hd__decap_3
XFILLER_41_215 VGND VGND VPWR VPWR sky130_fd_sc_hd__decap_3
XFILLER_54_587 VGND VGND VPWR VPWR sky130_fd_sc_hd__fill_1
XFILLER_54_598 VGND VGND VPWR VPWR sky130_fd_sc_hd__decap_3
XFILLER_81_362 VGND VGND VPWR VPWR sky130_fd_sc_hd__decap_3
XFILLER_41_237 VGND VGND VPWR VPWR sky130_fd_sc_hd__decap_3
X_6948_ _6968_/CLK _6948_/D VGND VGND VPWR VPWR _6948_/Q sky130_fd_sc_hd__dfxtp_2
X_6879_ _6959_/CLK _6879_/D VGND VGND VPWR VPWR _6879_/Q sky130_fd_sc_hd__dfxtp_2
XFILLER_10_613 VGND VGND VPWR VPWR sky130_fd_sc_hd__decap_3
XFILLER_22_473 VGND VGND VPWR VPWR sky130_fd_sc_hd__decap_3
XFILLER_108_501 VGND VGND VPWR VPWR sky130_fd_sc_hd__decap_3
XFILLER_10_657 VGND VGND VPWR VPWR sky130_fd_sc_hd__decap_3
XFILLER_6_628 VGND VGND VPWR VPWR sky130_fd_sc_hd__decap_3
XFILLER_108_545 VGND VGND VPWR VPWR sky130_fd_sc_hd__decap_3
XFILLER_108_578 VGND VGND VPWR VPWR sky130_fd_sc_hd__decap_3
XTAP_TAPCELL_ROW_114_1618 VGND VPWR sky130_fd_sc_hd__tapvpwrvgnd_1
XFILLER_108_589 VGND VGND VPWR VPWR sky130_fd_sc_hd__decap_3
Xhold680 _6816_/Q VGND VGND VPWR VPWR _6816_/D sky130_fd_sc_hd__dlygate4sd3_1
XFILLER_1_377 VGND VGND VPWR VPWR sky130_fd_sc_hd__decap_3
XFILLER_89_462 VGND VGND VPWR VPWR sky130_fd_sc_hd__decap_3
Xhold691 _6920_/Q VGND VGND VPWR VPWR _6920_/D sky130_fd_sc_hd__dlygate4sd3_1
XFILLER_1_399 VGND VGND VPWR VPWR sky130_fd_sc_hd__fill_1
XFILLER_49_326 VGND VGND VPWR VPWR sky130_fd_sc_hd__decap_3
XFILLER_49_337 VGND VGND VPWR VPWR sky130_fd_sc_hd__decap_3
XFILLER_76_101 VGND VGND VPWR VPWR sky130_fd_sc_hd__fill_2
XFILLER_77_635 VGND VGND VPWR VPWR sky130_fd_sc_hd__decap_3
XFILLER_64_307 VGND VGND VPWR VPWR sky130_fd_sc_hd__fill_1
XFILLER_77_668 VGND VGND VPWR VPWR sky130_fd_sc_hd__decap_3
XFILLER_77_679 VGND VGND VPWR VPWR sky130_fd_sc_hd__decap_3
XFILLER_92_616 VGND VGND VPWR VPWR sky130_fd_sc_hd__decap_3
XFILLER_64_329 VGND VGND VPWR VPWR sky130_fd_sc_hd__decap_3
XFILLER_76_178 VGND VGND VPWR VPWR sky130_fd_sc_hd__decap_3
XFILLER_17_223 VGND VGND VPWR VPWR sky130_fd_sc_hd__fill_1
XFILLER_17_234 VGND VGND VPWR VPWR sky130_fd_sc_hd__decap_3
XFILLER_91_137 VGND VGND VPWR VPWR sky130_fd_sc_hd__decap_3
XFILLER_17_256 VGND VGND VPWR VPWR sky130_fd_sc_hd__decap_3
XFILLER_45_576 VGND VGND VPWR VPWR sky130_fd_sc_hd__decap_3
XFILLER_32_237 VGND VGND VPWR VPWR sky130_fd_sc_hd__decap_3
XFILLER_32_248 VGND VGND VPWR VPWR sky130_fd_sc_hd__decap_3
XTAP_TAPCELL_ROW_15_435 VGND VPWR sky130_fd_sc_hd__tapvpwrvgnd_1
XFILLER_60_579 VGND VGND VPWR VPWR sky130_fd_sc_hd__decap_3
XTAP_TAPCELL_ROW_43_766 VGND VPWR sky130_fd_sc_hd__tapvpwrvgnd_1
XFILLER_9_477 VGND VGND VPWR VPWR sky130_fd_sc_hd__decap_3
XFILLER_5_650 VGND VGND VPWR VPWR sky130_fd_sc_hd__decap_3
XFILLER_114_504 VGND VGND VPWR VPWR sky130_fd_sc_hd__decap_3
XFILLER_114_548 VGND VGND VPWR VPWR sky130_fd_sc_hd__decap_3
XFILLER_4_182 VGND VGND VPWR VPWR sky130_fd_sc_hd__decap_3
XFILLER_4_20 VGND VGND VPWR VPWR sky130_fd_sc_hd__decap_3
X_4230_ _7227_/Q _4331_/A2 _5108_/S _7291_/Q _4229_/X VGND VGND VPWR VPWR _4230_/X
+ sky130_fd_sc_hd__a221o_2
XFILLER_99_237 VGND VGND VPWR VPWR sky130_fd_sc_hd__decap_3
XFILLER_68_613 VGND VGND VPWR VPWR sky130_fd_sc_hd__decap_3
X_4161_ _7265_/Q _4422_/A2 _4430_/A2 _7233_/Q _4160_/X VGND VGND VPWR VPWR _4161_/X
+ sky130_fd_sc_hd__a221o_2
XFILLER_68_657 VGND VGND VPWR VPWR sky130_fd_sc_hd__decap_3
XFILLER_55_307 VGND VGND VPWR VPWR sky130_fd_sc_hd__decap_3
X_4092_ _7366_/Q _4093_/B _4267_/B1 _7174_/Q _4091_/X VGND VGND VPWR VPWR _4092_/X
+ sky130_fd_sc_hd__a221o_2
XFILLER_83_638 VGND VGND VPWR VPWR sky130_fd_sc_hd__decap_3
XFILLER_48_392 VGND VGND VPWR VPWR sky130_fd_sc_hd__decap_3
XFILLER_63_340 VGND VGND VPWR VPWR sky130_fd_sc_hd__decap_3
XFILLER_76_690 VGND VGND VPWR VPWR sky130_fd_sc_hd__fill_1
XFILLER_36_587 VGND VGND VPWR VPWR sky130_fd_sc_hd__fill_1
XFILLER_91_671 VGND VGND VPWR VPWR sky130_fd_sc_hd__fill_1
XFILLER_91_682 VGND VGND VPWR VPWR sky130_fd_sc_hd__decap_3
Xplace340 _4349_/B1 VGND VGND VPWR VPWR _4421_/A2 sky130_fd_sc_hd__buf_2
X_6802_ _6941_/CLK _6802_/D VGND VGND VPWR VPWR _6802_/Q sky130_fd_sc_hd__dfxtp_2
XFILLER_36_598 VGND VGND VPWR VPWR sky130_fd_sc_hd__decap_3
Xplace373 _5151_/A VGND VGND VPWR VPWR _3991_/A sky130_fd_sc_hd__buf_2
Xplace362 _5159_/S VGND VGND VPWR VPWR _5157_/S sky130_fd_sc_hd__buf_2
Xplace351 _4337_/B VGND VGND VPWR VPWR _4312_/B sky130_fd_sc_hd__buf_2
X_4994_ _5114_/A _4275_/A _4987_/A _5033_/B2 VGND VGND VPWR VPWR _4994_/X sky130_fd_sc_hd__a22o_2
XFILLER_51_579 VGND VGND VPWR VPWR sky130_fd_sc_hd__decap_3
Xplace384 _4279_/B1 VGND VGND VPWR VPWR _4348_/B1 sky130_fd_sc_hd__buf_2
Xplace395 _5340_/S VGND VGND VPWR VPWR _5323_/S sky130_fd_sc_hd__buf_2
X_6733_ clkload9/A _6733_/D VGND VGND VPWR VPWR _6733_/Q sky130_fd_sc_hd__dfxtp_2
X_3945_ _7367_/Q _4488_/A0 _3945_/S VGND VGND VPWR VPWR _7367_/D sky130_fd_sc_hd__mux2_2
X_6664_ _6667_/A VGND VGND VPWR VPWR _6664_/Y sky130_fd_sc_hd__inv_2
XFILLER_31_281 VGND VGND VPWR VPWR sky130_fd_sc_hd__decap_3
X_5615_ _5615_/A _5622_/B VGND VGND VPWR VPWR _7020_/D sky130_fd_sc_hd__or2_2
X_3876_ _6858_/Q _3879_/B1 _3892_/B1 _6898_/Q VGND VGND VPWR VPWR _3876_/X sky130_fd_sc_hd__a22o_2
X_6595_ _6596_/A VGND VGND VPWR VPWR _6595_/Y sky130_fd_sc_hd__inv_2
XFILLER_3_609 VGND VGND VPWR VPWR sky130_fd_sc_hd__decap_3
XFILLER_105_526 VGND VGND VPWR VPWR sky130_fd_sc_hd__decap_3
XFILLER_105_559 VGND VGND VPWR VPWR sky130_fd_sc_hd__fill_1
X_7216_ _7311_/CLK _7216_/D _6496_/Y VGND VGND VPWR VPWR _7216_/Q sky130_fd_sc_hd__dfrtp_2
X_4428_ _7335_/Q _3945_/S _4428_/B1 _7143_/Q VGND VGND VPWR VPWR _4428_/X sky130_fd_sc_hd__a22o_2
XFILLER_113_570 VGND VGND VPWR VPWR sky130_fd_sc_hd__decap_3
XFILLER_48_26 VGND VGND VPWR VPWR sky130_fd_sc_hd__fill_2
XFILLER_59_635 VGND VGND VPWR VPWR sky130_fd_sc_hd__decap_3
XFILLER_86_421 VGND VGND VPWR VPWR sky130_fd_sc_hd__decap_3
X_7147_ _7307_/CLK _7147_/D _6427_/Y VGND VGND VPWR VPWR _7147_/Q sky130_fd_sc_hd__dfrtp_2
X_4359_ _4367_/C _4367_/A _4367_/B VGND VGND VPWR VPWR _5071_/B sky130_fd_sc_hd__nand3b_2
XFILLER_98_292 VGND VGND VPWR VPWR sky130_fd_sc_hd__decap_3
XFILLER_100_253 VGND VGND VPWR VPWR sky130_fd_sc_hd__decap_3
XFILLER_104_21 VGND VGND VPWR VPWR sky130_fd_sc_hd__decap_3
XFILLER_59_668 VGND VGND VPWR VPWR sky130_fd_sc_hd__decap_3
XFILLER_59_679 VGND VGND VPWR VPWR sky130_fd_sc_hd__decap_3
XFILLER_74_616 VGND VGND VPWR VPWR sky130_fd_sc_hd__decap_3
X_7078_ _7406_/CLK _7078_/D _6358_/Y VGND VGND VPWR VPWR _7078_/Q sky130_fd_sc_hd__dfrtp_2
XFILLER_104_32 VGND VGND VPWR VPWR sky130_fd_sc_hd__decap_3
XFILLER_46_329 VGND VGND VPWR VPWR sky130_fd_sc_hd__decap_3
XFILLER_64_14 VGND VGND VPWR VPWR sky130_fd_sc_hd__decap_3
XFILLER_73_159 VGND VGND VPWR VPWR sky130_fd_sc_hd__decap_3
XFILLER_27_576 VGND VGND VPWR VPWR sky130_fd_sc_hd__decap_3
XFILLER_42_513 VGND VGND VPWR VPWR sky130_fd_sc_hd__decap_3
XFILLER_54_362 VGND VGND VPWR VPWR sky130_fd_sc_hd__fill_2
XFILLER_82_660 VGND VGND VPWR VPWR sky130_fd_sc_hd__decap_3
XFILLER_81_181 VGND VGND VPWR VPWR sky130_fd_sc_hd__decap_3
XTAP_TAPCELL_ROW_64_1016 VGND VPWR sky130_fd_sc_hd__tapvpwrvgnd_1
XFILLER_14_259 VGND VGND VPWR VPWR sky130_fd_sc_hd__fill_1
XFILLER_42_557 VGND VGND VPWR VPWR sky130_fd_sc_hd__decap_3
Xfanout30 _6567_/A VGND VGND VPWR VPWR _6603_/A sky130_fd_sc_hd__clkdlybuf4s25_1
XFILLER_22_270 VGND VGND VPWR VPWR sky130_fd_sc_hd__decap_3
Xfanout41 fanout46/X VGND VGND VPWR VPWR _6569_/A sky130_fd_sc_hd__buf_1
Xfanout52 fanout73/A VGND VGND VPWR VPWR _6683_/A sky130_fd_sc_hd__clkdlybuf4s25_1
Xfanout63 _6582_/A VGND VGND VPWR VPWR _6622_/A sky130_fd_sc_hd__buf_2
Xfanout74 reset VGND VGND VPWR VPWR _6350_/A sky130_fd_sc_hd__buf_1
XTAP_TAPCELL_ROW_40_736 VGND VPWR sky130_fd_sc_hd__tapvpwrvgnd_1
XFILLER_10_421 VGND VGND VPWR VPWR sky130_fd_sc_hd__decap_3
XFILLER_10_432 VGND VGND VPWR VPWR sky130_fd_sc_hd__decap_3
XFILLER_108_342 VGND VGND VPWR VPWR sky130_fd_sc_hd__decap_3
XTAP_TAPCELL_ROW_20_493 VGND VPWR sky130_fd_sc_hd__tapvpwrvgnd_1
XFILLER_89_44 VGND VGND VPWR VPWR sky130_fd_sc_hd__decap_3
XFILLER_2_631 VGND VGND VPWR VPWR sky130_fd_sc_hd__decap_3
XTAP_TAPCELL_ROW_75_1156 VGND VPWR sky130_fd_sc_hd__tapvpwrvgnd_1
XFILLER_111_529 VGND VGND VPWR VPWR sky130_fd_sc_hd__decap_3
XFILLER_2_675 VGND VGND VPWR VPWR sky130_fd_sc_hd__decap_3
XFILLER_96_218 VGND VGND VPWR VPWR sky130_fd_sc_hd__decap_3
XFILLER_104_581 VGND VGND VPWR VPWR sky130_fd_sc_hd__decap_3
XFILLER_104_592 VGND VGND VPWR VPWR sky130_fd_sc_hd__decap_3
XFILLER_77_410 VGND VGND VPWR VPWR sky130_fd_sc_hd__decap_3
XFILLER_89_281 VGND VGND VPWR VPWR sky130_fd_sc_hd__decap_3
XFILLER_37_307 VGND VGND VPWR VPWR sky130_fd_sc_hd__decap_3
XFILLER_65_638 VGND VGND VPWR VPWR sky130_fd_sc_hd__decap_3
XFILLER_77_498 VGND VGND VPWR VPWR sky130_fd_sc_hd__decap_3
XFILLER_92_424 VGND VGND VPWR VPWR sky130_fd_sc_hd__decap_3
XTAP_TAPCELL_ROW_48_825 VGND VPWR sky130_fd_sc_hd__tapvpwrvgnd_1
XFILLER_58_690 VGND VGND VPWR VPWR sky130_fd_sc_hd__fill_1
XPHY_EDGE_ROW_32_Left_149 VGND VGND VPWR VPWR sky130_fd_sc_hd__decap_3
XFILLER_18_554 VGND VGND VPWR VPWR sky130_fd_sc_hd__decap_3
XFILLER_18_587 VGND VGND VPWR VPWR sky130_fd_sc_hd__fill_1
XFILLER_73_671 VGND VGND VPWR VPWR sky130_fd_sc_hd__fill_1
XFILLER_80_619 VGND VGND VPWR VPWR sky130_fd_sc_hd__decap_3
XFILLER_18_598 VGND VGND VPWR VPWR sky130_fd_sc_hd__decap_3
XFILLER_60_321 VGND VGND VPWR VPWR sky130_fd_sc_hd__decap_3
XFILLER_73_682 VGND VGND VPWR VPWR sky130_fd_sc_hd__decap_3
XTAP_TAPCELL_ROW_86_1285 VGND VPWR sky130_fd_sc_hd__tapvpwrvgnd_1
XTAP_TAPCELL_ROW_28_593 VGND VPWR sky130_fd_sc_hd__tapvpwrvgnd_1
XTAP_TAPCELL_ROW_28_582 VGND VPWR sky130_fd_sc_hd__tapvpwrvgnd_1
XFILLER_33_579 VGND VGND VPWR VPWR sky130_fd_sc_hd__decap_3
XFILLER_60_365 VGND VGND VPWR VPWR sky130_fd_sc_hd__decap_3
XFILLER_72_192 VGND VGND VPWR VPWR sky130_fd_sc_hd__decap_3
XFILLER_20_229 VGND VGND VPWR VPWR sky130_fd_sc_hd__decap_3
X_3730_ _6956_/Q _3889_/A2 _3889_/B1 _6950_/Q _3729_/X VGND VGND VPWR VPWR _3730_/X
+ sky130_fd_sc_hd__a221o_2
X_3661_ _3991_/B _3665_/B VGND VGND VPWR VPWR _3661_/X sky130_fd_sc_hd__and2_4
XFILLER_9_263 VGND VGND VPWR VPWR sky130_fd_sc_hd__decap_3
XFILLER_62_3 VGND VGND VPWR VPWR sky130_fd_sc_hd__decap_3
Xclkload11 _6966_/CLK VGND VGND VPWR VPWR clkload11/Y sky130_fd_sc_hd__clkinv_2
Xclkload22 _6965_/CLK VGND VGND VPWR VPWR clkload22/Y sky130_fd_sc_hd__clkinv_2
Xclkload33 _7395_/CLK VGND VGND VPWR VPWR clkload33/X sky130_fd_sc_hd__clkbuf_1
X_6380_ _6608_/A VGND VGND VPWR VPWR _6380_/Y sky130_fd_sc_hd__inv_2
X_5400_ _5400_/A0 _5011_/X _5409_/S VGND VGND VPWR VPWR _7133_/D sky130_fd_sc_hd__mux2_2
X_3592_ _4292_/B _3620_/C _3591_/Y VGND VGND VPWR VPWR _3592_/X sky130_fd_sc_hd__a21o_2
XPHY_EDGE_ROW_41_Left_158 VGND VGND VPWR VPWR sky130_fd_sc_hd__decap_3
X_5331_ _5331_/A0 _5011_/X _5340_/S VGND VGND VPWR VPWR _7165_/D sky130_fd_sc_hd__mux2_2
XFILLER_114_323 VGND VGND VPWR VPWR sky130_fd_sc_hd__fill_1
XFILLER_114_345 VGND VGND VPWR VPWR sky130_fd_sc_hd__decap_3
XFILLER_5_480 VGND VGND VPWR VPWR sky130_fd_sc_hd__decap_3
XFILLER_102_507 VGND VGND VPWR VPWR sky130_fd_sc_hd__decap_3
X_7001_ _7144_/CLK _7001_/D _6281_/Y VGND VGND VPWR VPWR _7001_/Q sky130_fd_sc_hd__dfrtp_2
X_5262_ hold993/X _4978_/X _5262_/S VGND VGND VPWR VPWR _7199_/D sky130_fd_sc_hd__mux2_2
XFILLER_114_389 VGND VGND VPWR VPWR sky130_fd_sc_hd__decap_3
X_4213_ _7292_/Q _4269_/B1 _4261_/A2 _7356_/Q _4248_/A VGND VGND VPWR VPWR _4213_/X
+ sky130_fd_sc_hd__a221o_2
XFILLER_110_551 VGND VGND VPWR VPWR sky130_fd_sc_hd__decap_3
X_4144_ _7362_/Q _4261_/A2 _4348_/A2 _7170_/Q VGND VGND VPWR VPWR _4144_/X sky130_fd_sc_hd__a22o_2
XFILLER_110_584 VGND VGND VPWR VPWR sky130_fd_sc_hd__decap_3
XFILLER_18_29 VGND VGND VPWR VPWR sky130_fd_sc_hd__fill_1
XFILLER_28_329 VGND VGND VPWR VPWR sky130_fd_sc_hd__decap_3
XFILLER_56_616 VGND VGND VPWR VPWR sky130_fd_sc_hd__decap_3
XPHY_EDGE_ROW_50_Left_167 VGND VGND VPWR VPWR sky130_fd_sc_hd__decap_3
XFILLER_110_595 VGND VGND VPWR VPWR sky130_fd_sc_hd__decap_3
XFILLER_95_295 VGND VGND VPWR VPWR sky130_fd_sc_hd__decap_3
X_4075_ _7211_/Q _3945_/S _4837_/S _7307_/Q VGND VGND VPWR VPWR _4075_/X sky130_fd_sc_hd__a22o_2
XFILLER_24_502 VGND VGND VPWR VPWR sky130_fd_sc_hd__decap_3
XFILLER_64_660 VGND VGND VPWR VPWR sky130_fd_sc_hd__decap_3
XFILLER_51_310 VGND VGND VPWR VPWR sky130_fd_sc_hd__decap_3
XFILLER_24_557 VGND VGND VPWR VPWR sky130_fd_sc_hd__decap_3
X_6716_ _7403_/CLK _6716_/D VGND VGND VPWR VPWR _6716_/Q sky130_fd_sc_hd__dfxtp_2
X_4977_ _4977_/A _4977_/B VGND VGND VPWR VPWR _6993_/D sky130_fd_sc_hd__nor2_2
Xclkload5 clkload5/A VGND VGND VPWR VPWR clkload5/X sky130_fd_sc_hd__clkbuf_16
X_3928_ hold985/X _3991_/A _3927_/X VGND VGND VPWR VPWR _7375_/D sky130_fd_sc_hd__o21a_2
X_6647_ _6653_/A VGND VGND VPWR VPWR _6647_/Y sky130_fd_sc_hd__inv_2
X_3859_ _6924_/Q _3918_/A2 _3926_/B1 _6788_/Q _3858_/X VGND VGND VPWR VPWR _3859_/X
+ sky130_fd_sc_hd__a221o_2
X_6578_ _6581_/A VGND VGND VPWR VPWR _6578_/Y sky130_fd_sc_hd__inv_2
XFILLER_78_218 VGND VGND VPWR VPWR sky130_fd_sc_hd__fill_1
XFILLER_59_421 VGND VGND VPWR VPWR sky130_fd_sc_hd__decap_3
XFILLER_59_69 VGND VGND VPWR VPWR sky130_fd_sc_hd__decap_3
XFILLER_115_42 VGND VGND VPWR VPWR sky130_fd_sc_hd__decap_3
XFILLER_59_432 VGND VGND VPWR VPWR sky130_fd_sc_hd__decap_3
XFILLER_101_573 VGND VGND VPWR VPWR sky130_fd_sc_hd__decap_3
XFILLER_115_75 VGND VGND VPWR VPWR sky130_fd_sc_hd__decap_3
XFILLER_47_638 VGND VGND VPWR VPWR sky130_fd_sc_hd__decap_3
XFILLER_59_487 VGND VGND VPWR VPWR sky130_fd_sc_hd__decap_3
XFILLER_74_413 VGND VGND VPWR VPWR sky130_fd_sc_hd__decap_3
XFILLER_86_262 VGND VGND VPWR VPWR sky130_fd_sc_hd__fill_2
XTAP_TAPCELL_ROW_70_1097 VGND VPWR sky130_fd_sc_hd__tapvpwrvgnd_1
XTAP_TAPCELL_ROW_70_1086 VGND VPWR sky130_fd_sc_hd__tapvpwrvgnd_1
XFILLER_74_435 VGND VGND VPWR VPWR sky130_fd_sc_hd__decap_3
XFILLER_75_57 VGND VGND VPWR VPWR sky130_fd_sc_hd__fill_2
XFILLER_75_68 VGND VGND VPWR VPWR sky130_fd_sc_hd__fill_1
XFILLER_75_79 VGND VGND VPWR VPWR sky130_fd_sc_hd__decap_3
XFILLER_55_671 VGND VGND VPWR VPWR sky130_fd_sc_hd__fill_1
XFILLER_62_619 VGND VGND VPWR VPWR sky130_fd_sc_hd__decap_3
XFILLER_15_535 VGND VGND VPWR VPWR sky130_fd_sc_hd__decap_3
XFILLER_27_373 VGND VGND VPWR VPWR sky130_fd_sc_hd__decap_3
XFILLER_55_682 VGND VGND VPWR VPWR sky130_fd_sc_hd__decap_3
XFILLER_91_12 VGND VGND VPWR VPWR sky130_fd_sc_hd__decap_3
XFILLER_15_579 VGND VGND VPWR VPWR sky130_fd_sc_hd__decap_3
XFILLER_70_663 VGND VGND VPWR VPWR sky130_fd_sc_hd__decap_3
XFILLER_42_365 VGND VGND VPWR VPWR sky130_fd_sc_hd__decap_3
XFILLER_91_78 VGND VGND VPWR VPWR sky130_fd_sc_hd__fill_2
XTAP_TAPCELL_ROW_53_883 VGND VPWR sky130_fd_sc_hd__tapvpwrvgnd_1
XTAP_TAPCELL_ROW_25_552 VGND VPWR sky130_fd_sc_hd__tapvpwrvgnd_1
XFILLER_24_94 VGND VGND VPWR VPWR sky130_fd_sc_hd__decap_3
XFILLER_10_251 VGND VGND VPWR VPWR sky130_fd_sc_hd__fill_1
XFILLER_108_161 VGND VGND VPWR VPWR sky130_fd_sc_hd__fill_1
XFILLER_109_662 VGND VGND VPWR VPWR sky130_fd_sc_hd__decap_3
XFILLER_109_673 VGND VGND VPWR VPWR sky130_fd_sc_hd__decap_3
XFILLER_40_93 VGND VGND VPWR VPWR sky130_fd_sc_hd__decap_3
XFILLER_6_288 VGND VGND VPWR VPWR sky130_fd_sc_hd__decap_3
XFILLER_97_505 VGND VGND VPWR VPWR sky130_fd_sc_hd__decap_3
XFILLER_111_337 VGND VGND VPWR VPWR sky130_fd_sc_hd__fill_1
XFILLER_2_461 VGND VGND VPWR VPWR sky130_fd_sc_hd__decap_3
XFILLER_2_483 VGND VGND VPWR VPWR sky130_fd_sc_hd__decap_3
XFILLER_97_538 VGND VGND VPWR VPWR sky130_fd_sc_hd__decap_3
XFILLER_1_21 VGND VGND VPWR VPWR sky130_fd_sc_hd__fill_2
XFILLER_38_616 VGND VGND VPWR VPWR sky130_fd_sc_hd__decap_3
XFILLER_65_402 VGND VGND VPWR VPWR sky130_fd_sc_hd__decap_3
XFILLER_65_424 VGND VGND VPWR VPWR sky130_fd_sc_hd__decap_3
XFILLER_77_262 VGND VGND VPWR VPWR sky130_fd_sc_hd__decap_3
XTAP_TAPCELL_ROW_88_1303 VGND VPWR sky130_fd_sc_hd__tapvpwrvgnd_1
XFILLER_77_284 VGND VGND VPWR VPWR sky130_fd_sc_hd__decap_3
XFILLER_92_221 VGND VGND VPWR VPWR sky130_fd_sc_hd__decap_3
XFILLER_18_351 VGND VGND VPWR VPWR sky130_fd_sc_hd__decap_3
XFILLER_1_76 VGND VGND VPWR VPWR sky130_fd_sc_hd__fill_2
XFILLER_46_660 VGND VGND VPWR VPWR sky130_fd_sc_hd__decap_3
XFILLER_52_107 VGND VGND VPWR VPWR sky130_fd_sc_hd__fill_1
XFILLER_65_479 VGND VGND VPWR VPWR sky130_fd_sc_hd__decap_3
XFILLER_80_405 VGND VGND VPWR VPWR sky130_fd_sc_hd__fill_2
XFILLER_45_181 VGND VGND VPWR VPWR sky130_fd_sc_hd__decap_3
XFILLER_65_90 VGND VGND VPWR VPWR sky130_fd_sc_hd__decap_3
XFILLER_33_354 VGND VGND VPWR VPWR sky130_fd_sc_hd__decap_3
XFILLER_61_641 VGND VGND VPWR VPWR sky130_fd_sc_hd__decap_3
X_4831_ _4969_/B _4827_/X _4828_/X _4830_/X VGND VGND VPWR VPWR _5657_/A sky130_fd_sc_hd__a211o_2
XFILLER_21_505 VGND VGND VPWR VPWR sky130_fd_sc_hd__decap_3
XFILLER_21_538 VGND VGND VPWR VPWR sky130_fd_sc_hd__decap_3
XFILLER_61_685 VGND VGND VPWR VPWR sky130_fd_sc_hd__decap_3
X_4762_ _4762_/A _4762_/B VGND VGND VPWR VPWR _4762_/Y sky130_fd_sc_hd__nor2_2
X_6501_ _6596_/A VGND VGND VPWR VPWR _6501_/Y sky130_fd_sc_hd__inv_2
X_4693_ _7007_/Q _4750_/B VGND VGND VPWR VPWR _4728_/A sky130_fd_sc_hd__nand2_2
X_3713_ _3733_/C VGND VGND VPWR VPWR _3746_/C sky130_fd_sc_hd__inv_4
XTAP_TAPCELL_ROW_99_1443 VGND VPWR sky130_fd_sc_hd__tapvpwrvgnd_1
X_6432_ _6632_/A VGND VGND VPWR VPWR _6432_/Y sky130_fd_sc_hd__inv_2
X_3644_ _3629_/Y _3642_/X _3833_/S VGND VGND VPWR VPWR _4664_/B sky130_fd_sc_hd__o21a_2
XFILLER_115_632 VGND VGND VPWR VPWR sky130_fd_sc_hd__decap_3
X_6363_ _6364_/A VGND VGND VPWR VPWR _6363_/Y sky130_fd_sc_hd__inv_2
X_3575_ _7156_/Q _3366_/X _4279_/B1 _7124_/Q _3574_/X VGND VGND VPWR VPWR _3575_/X
+ sky130_fd_sc_hd__a221o_2
XFILLER_114_153 VGND VGND VPWR VPWR sky130_fd_sc_hd__decap_3
XFILLER_115_665 VGND VGND VPWR VPWR sky130_fd_sc_hd__decap_3
XFILLER_115_676 VGND VGND VPWR VPWR sky130_fd_sc_hd__decap_3
X_6294_ _6570_/A VGND VGND VPWR VPWR _6294_/Y sky130_fd_sc_hd__inv_2
XFILLER_114_175 VGND VGND VPWR VPWR sky130_fd_sc_hd__fill_1
X_5245_ _5245_/A0 _4836_/X _5256_/S VGND VGND VPWR VPWR _7207_/D sky130_fd_sc_hd__mux2_2
XFILLER_102_348 VGND VGND VPWR VPWR sky130_fd_sc_hd__decap_3
XFILLER_114_197 VGND VGND VPWR VPWR sky130_fd_sc_hd__decap_3
XFILLER_29_638 VGND VGND VPWR VPWR sky130_fd_sc_hd__decap_3
XFILLER_56_413 VGND VGND VPWR VPWR sky130_fd_sc_hd__decap_3
XFILLER_96_560 VGND VGND VPWR VPWR sky130_fd_sc_hd__decap_3
XFILLER_56_424 VGND VGND VPWR VPWR sky130_fd_sc_hd__fill_2
XFILLER_68_295 VGND VGND VPWR VPWR sky130_fd_sc_hd__decap_3
XFILLER_83_210 VGND VGND VPWR VPWR sky130_fd_sc_hd__decap_3
XFILLER_83_232 VGND VGND VPWR VPWR sky130_fd_sc_hd__decap_3
XFILLER_28_159 VGND VGND VPWR VPWR sky130_fd_sc_hd__fill_2
XFILLER_44_619 VGND VGND VPWR VPWR sky130_fd_sc_hd__decap_3
XFILLER_56_468 VGND VGND VPWR VPWR sky130_fd_sc_hd__decap_3
XFILLER_83_276 VGND VGND VPWR VPWR sky130_fd_sc_hd__decap_3
X_4058_ _7244_/Q _4430_/A2 _4459_/C1 _7180_/Q _4057_/X VGND VGND VPWR VPWR _4058_/X
+ sky130_fd_sc_hd__a221o_2
XTAP_TAPCELL_ROW_108_1550 VGND VPWR sky130_fd_sc_hd__tapvpwrvgnd_1
XFILLER_37_671 VGND VGND VPWR VPWR sky130_fd_sc_hd__fill_1
XFILLER_37_682 VGND VGND VPWR VPWR sky130_fd_sc_hd__decap_3
XFILLER_71_449 VGND VGND VPWR VPWR sky130_fd_sc_hd__decap_3
XFILLER_83_287 VGND VGND VPWR VPWR sky130_fd_sc_hd__fill_1
XFILLER_24_332 VGND VGND VPWR VPWR sky130_fd_sc_hd__decap_3
XFILLER_52_663 VGND VGND VPWR VPWR sky130_fd_sc_hd__decap_3
XFILLER_24_365 VGND VGND VPWR VPWR sky130_fd_sc_hd__decap_3
XFILLER_61_15 VGND VGND VPWR VPWR sky130_fd_sc_hd__decap_3
XFILLER_51_184 VGND VGND VPWR VPWR sky130_fd_sc_hd__fill_2
XFILLER_51_195 VGND VGND VPWR VPWR sky130_fd_sc_hd__fill_1
XTAP_TAPCELL_ROW_22_511 VGND VPWR sky130_fd_sc_hd__tapvpwrvgnd_1
XFILLER_20_560 VGND VGND VPWR VPWR sky130_fd_sc_hd__decap_3
XTAP_TAPCELL_ROW_50_853 VGND VPWR sky130_fd_sc_hd__tapvpwrvgnd_1
XFILLER_106_610 VGND VGND VPWR VPWR sky130_fd_sc_hd__decap_3
XFILLER_106_643 VGND VGND VPWR VPWR sky130_fd_sc_hd__fill_1
XFILLER_3_214 VGND VGND VPWR VPWR sky130_fd_sc_hd__decap_3
XFILLER_3_236 VGND VGND VPWR VPWR sky130_fd_sc_hd__decap_3
XFILLER_106_654 VGND VGND VPWR VPWR sky130_fd_sc_hd__decap_3
XTAP_TAPCELL_ROW_72_1115 VGND VPWR sky130_fd_sc_hd__tapvpwrvgnd_1
XFILLER_105_164 VGND VGND VPWR VPWR sky130_fd_sc_hd__decap_3
XFILLER_106_687 VGND VGND VPWR VPWR sky130_fd_sc_hd__decap_3
XFILLER_10_85 VGND VGND VPWR VPWR sky130_fd_sc_hd__decap_3
XFILLER_59_240 VGND VGND VPWR VPWR sky130_fd_sc_hd__fill_1
XFILLER_86_56 VGND VGND VPWR VPWR sky130_fd_sc_hd__decap_3
XFILLER_47_402 VGND VGND VPWR VPWR sky130_fd_sc_hd__decap_3
XFILLER_59_251 VGND VGND VPWR VPWR sky130_fd_sc_hd__decap_3
XFILLER_59_262 VGND VGND VPWR VPWR sky130_fd_sc_hd__decap_3
XFILLER_87_582 VGND VGND VPWR VPWR sky130_fd_sc_hd__decap_3
XFILLER_19_83 VGND VGND VPWR VPWR sky130_fd_sc_hd__fill_1
XFILLER_47_435 VGND VGND VPWR VPWR sky130_fd_sc_hd__decap_3
XFILLER_47_446 VGND VGND VPWR VPWR sky130_fd_sc_hd__fill_2
XFILLER_59_284 VGND VGND VPWR VPWR sky130_fd_sc_hd__decap_3
XFILLER_74_221 VGND VGND VPWR VPWR sky130_fd_sc_hd__decap_3
XTAP_TAPCELL_ROW_58_942 VGND VPWR sky130_fd_sc_hd__tapvpwrvgnd_1
XFILLER_28_660 VGND VGND VPWR VPWR sky130_fd_sc_hd__decap_3
XFILLER_74_265 VGND VGND VPWR VPWR sky130_fd_sc_hd__decap_3
XTAP_TAPCELL_ROW_58_953 VGND VPWR sky130_fd_sc_hd__tapvpwrvgnd_1
XFILLER_62_427 VGND VGND VPWR VPWR sky130_fd_sc_hd__decap_3
XTAP_TAPCELL_ROW_2_280 VGND VPWR sky130_fd_sc_hd__tapvpwrvgnd_1
XFILLER_43_641 VGND VGND VPWR VPWR sky130_fd_sc_hd__decap_3
XFILLER_55_490 VGND VGND VPWR VPWR sky130_fd_sc_hd__fill_2
XTAP_TAPCELL_ROW_83_1244 VGND VPWR sky130_fd_sc_hd__tapvpwrvgnd_1
XPHY_EDGE_ROW_106_Left_223 VGND VGND VPWR VPWR sky130_fd_sc_hd__decap_3
XFILLER_30_302 VGND VGND VPWR VPWR sky130_fd_sc_hd__decap_3
XFILLER_35_93 VGND VGND VPWR VPWR sky130_fd_sc_hd__decap_3
XFILLER_43_685 VGND VGND VPWR VPWR sky130_fd_sc_hd__decap_3
XFILLER_96_9 VGND VGND VPWR VPWR sky130_fd_sc_hd__decap_3
XFILLER_30_368 VGND VGND VPWR VPWR sky130_fd_sc_hd__decap_3
XFILLER_11_582 VGND VGND VPWR VPWR sky130_fd_sc_hd__decap_3
XFILLER_7_520 VGND VGND VPWR VPWR sky130_fd_sc_hd__decap_3
XFILLER_7_553 VGND VGND VPWR VPWR sky130_fd_sc_hd__decap_3
XFILLER_7_564 VGND VGND VPWR VPWR sky130_fd_sc_hd__decap_3
XFILLER_109_470 VGND VGND VPWR VPWR sky130_fd_sc_hd__decap_3
XFILLER_7_597 VGND VGND VPWR VPWR sky130_fd_sc_hd__decap_3
X_3360_ _3365_/A _5129_/B _3371_/A VGND VGND VPWR VPWR _3386_/B sky130_fd_sc_hd__mux2_2
XTAP_TAPCELL_ROW_94_1384 VGND VPWR sky130_fd_sc_hd__tapvpwrvgnd_1
XPHY_EDGE_ROW_115_Left_232 VGND VGND VPWR VPWR sky130_fd_sc_hd__decap_3
XFILLER_112_613 VGND VGND VPWR VPWR sky130_fd_sc_hd__decap_3
XFILLER_112_657 VGND VGND VPWR VPWR sky130_fd_sc_hd__decap_3
XFILLER_85_508 VGND VGND VPWR VPWR sky130_fd_sc_hd__decap_3
XFILLER_97_346 VGND VGND VPWR VPWR sky130_fd_sc_hd__decap_3
XFILLER_97_357 VGND VGND VPWR VPWR sky130_fd_sc_hd__decap_3
X_5030_ _6989_/Q _5044_/A VGND VGND VPWR VPWR _6989_/D sky130_fd_sc_hd__xor2_2
XFILLER_25_3 VGND VGND VPWR VPWR sky130_fd_sc_hd__fill_2
XFILLER_78_560 VGND VGND VPWR VPWR sky130_fd_sc_hd__decap_3
Xhold1209 _7144_/Q VGND VGND VPWR VPWR _5377_/A0 sky130_fd_sc_hd__dlygate4sd3_1
XFILLER_38_424 VGND VGND VPWR VPWR sky130_fd_sc_hd__decap_3
XFILLER_93_541 VGND VGND VPWR VPWR sky130_fd_sc_hd__decap_3
XFILLER_26_619 VGND VGND VPWR VPWR sky130_fd_sc_hd__decap_3
XFILLER_38_457 VGND VGND VPWR VPWR sky130_fd_sc_hd__decap_3
X_6981_ clkload7/A _6981_/D _6261_/Y VGND VGND VPWR VPWR _6981_/Q sky130_fd_sc_hd__dfrtp_2
XFILLER_19_671 VGND VGND VPWR VPWR sky130_fd_sc_hd__fill_1
XFILLER_19_682 VGND VGND VPWR VPWR sky130_fd_sc_hd__decap_3
XFILLER_25_107 VGND VGND VPWR VPWR sky130_fd_sc_hd__fill_2
XFILLER_25_129 VGND VGND VPWR VPWR sky130_fd_sc_hd__decap_3
XFILLER_53_416 VGND VGND VPWR VPWR sky130_fd_sc_hd__decap_3
XFILLER_65_276 VGND VGND VPWR VPWR sky130_fd_sc_hd__decap_3
XFILLER_65_287 VGND VGND VPWR VPWR sky130_fd_sc_hd__fill_2
XFILLER_93_585 VGND VGND VPWR VPWR sky130_fd_sc_hd__decap_3
XTAP_TAPCELL_ROW_0_239 VGND VPWR sky130_fd_sc_hd__tapvpwrvgnd_1
XFILLER_53_449 VGND VGND VPWR VPWR sky130_fd_sc_hd__decap_3
XFILLER_33_162 VGND VGND VPWR VPWR sky130_fd_sc_hd__decap_3
XFILLER_34_663 VGND VGND VPWR VPWR sky130_fd_sc_hd__decap_3
X_4814_ _4814_/A _4814_/B VGND VGND VPWR VPWR _4814_/Y sky130_fd_sc_hd__nor2_2
X_4745_ _4745_/A VGND VGND VPWR VPWR _4745_/Y sky130_fd_sc_hd__inv_2
XTAP_TAPCELL_ROW_103_1491 VGND VPWR sky130_fd_sc_hd__tapvpwrvgnd_1
XFILLER_107_429 VGND VGND VPWR VPWR sky130_fd_sc_hd__decap_3
X_4676_ _5648_/A _5067_/B _6985_/Q _6986_/Q _6987_/Q VGND VGND VPWR VPWR _5045_/B
+ sky130_fd_sc_hd__o2111a_2
X_7395_ _7395_/CLK _7395_/D _6675_/Y VGND VGND VPWR VPWR _7395_/Q sky130_fd_sc_hd__dfrtp_2
X_6415_ _6643_/A VGND VGND VPWR VPWR _6415_/Y sky130_fd_sc_hd__inv_2
X_3627_ _3746_/A _3746_/B _3733_/C VGND VGND VPWR VPWR _5660_/A sky130_fd_sc_hd__and3_2
X_6346_ _6672_/A VGND VGND VPWR VPWR _6346_/Y sky130_fd_sc_hd__inv_2
X_3558_ _7061_/Q _3577_/B VGND VGND VPWR VPWR _3558_/X sky130_fd_sc_hd__or2_2
XFILLER_103_635 VGND VGND VPWR VPWR sky130_fd_sc_hd__decap_3
XFILLER_115_473 VGND VGND VPWR VPWR sky130_fd_sc_hd__decap_3
XFILLER_102_112 VGND VGND VPWR VPWR sky130_fd_sc_hd__decap_3
XFILLER_103_668 VGND VGND VPWR VPWR sky130_fd_sc_hd__decap_3
XFILLER_88_368 VGND VGND VPWR VPWR sky130_fd_sc_hd__decap_3
X_6277_ _6278_/A VGND VGND VPWR VPWR _6277_/Y sky130_fd_sc_hd__inv_2
X_3489_ _7311_/Q _4471_/S _4285_/B1 _7343_/Q _3488_/X VGND VGND VPWR VPWR _3489_/X
+ sky130_fd_sc_hd__a221o_2
XFILLER_103_679 VGND VGND VPWR VPWR sky130_fd_sc_hd__decap_3
X_5228_ _5238_/B VGND VGND VPWR VPWR _5229_/B sky130_fd_sc_hd__inv_2
XFILLER_29_413 VGND VGND VPWR VPWR sky130_fd_sc_hd__decap_3
XFILLER_56_15 VGND VGND VPWR VPWR sky130_fd_sc_hd__decap_3
XFILLER_69_582 VGND VGND VPWR VPWR sky130_fd_sc_hd__decap_3
X_5159_ _5159_/A0 _4470_/X _5159_/S VGND VGND VPWR VPWR _7247_/D sky130_fd_sc_hd__mux2_2
XFILLER_44_405 VGND VGND VPWR VPWR sky130_fd_sc_hd__decap_3
XFILLER_56_265 VGND VGND VPWR VPWR sky130_fd_sc_hd__fill_1
XFILLER_84_563 VGND VGND VPWR VPWR sky130_fd_sc_hd__decap_3
XFILLER_112_21 VGND VGND VPWR VPWR sky130_fd_sc_hd__decap_3
XFILLER_112_32 VGND VGND VPWR VPWR sky130_fd_sc_hd__decap_3
XFILLER_16_118 VGND VGND VPWR VPWR sky130_fd_sc_hd__fill_2
XFILLER_44_416 VGND VGND VPWR VPWR sky130_fd_sc_hd__decap_3
XTAP_TAPCELL_ROW_55_912 VGND VPWR sky130_fd_sc_hd__tapvpwrvgnd_1
XFILLER_112_65 VGND VGND VPWR VPWR sky130_fd_sc_hd__decap_3
XFILLER_25_641 VGND VGND VPWR VPWR sky130_fd_sc_hd__decap_3
XFILLER_71_246 VGND VGND VPWR VPWR sky130_fd_sc_hd__decap_3
Xclkbuf_leaf_36_clk clkload2/A VGND VGND VPWR VPWR _7344_/CLK sky130_fd_sc_hd__clkbuf_16
XFILLER_24_162 VGND VGND VPWR VPWR sky130_fd_sc_hd__decap_3
XFILLER_25_685 VGND VGND VPWR VPWR sky130_fd_sc_hd__decap_3
XFILLER_52_460 VGND VGND VPWR VPWR sky130_fd_sc_hd__decap_3
XFILLER_72_58 VGND VGND VPWR VPWR sky130_fd_sc_hd__fill_2
XFILLER_12_324 VGND VGND VPWR VPWR sky130_fd_sc_hd__fill_2
XFILLER_24_184 VGND VGND VPWR VPWR sky130_fd_sc_hd__decap_3
XFILLER_24_195 VGND VGND VPWR VPWR sky130_fd_sc_hd__fill_1
XFILLER_40_622 VGND VGND VPWR VPWR sky130_fd_sc_hd__decap_3
XFILLER_40_666 VGND VGND VPWR VPWR sky130_fd_sc_hd__decap_3
XFILLER_4_501 VGND VGND VPWR VPWR sky130_fd_sc_hd__decap_3
XFILLER_21_62 VGND VGND VPWR VPWR sky130_fd_sc_hd__fill_1
XFILLER_106_451 VGND VGND VPWR VPWR sky130_fd_sc_hd__decap_3
XFILLER_4_545 VGND VGND VPWR VPWR sky130_fd_sc_hd__decap_3
XFILLER_4_578 VGND VGND VPWR VPWR sky130_fd_sc_hd__decap_3
XFILLER_4_589 VGND VGND VPWR VPWR sky130_fd_sc_hd__decap_3
XFILLER_79_302 VGND VGND VPWR VPWR sky130_fd_sc_hd__decap_3
XFILLER_106_495 VGND VGND VPWR VPWR sky130_fd_sc_hd__decap_3
XFILLER_79_335 VGND VGND VPWR VPWR sky130_fd_sc_hd__fill_1
XFILLER_79_346 VGND VGND VPWR VPWR sky130_fd_sc_hd__decap_3
XFILLER_102_690 VGND VGND VPWR VPWR sky130_fd_sc_hd__fill_1
XFILLER_47_254 VGND VGND VPWR VPWR sky130_fd_sc_hd__decap_3
XFILLER_75_541 VGND VGND VPWR VPWR sky130_fd_sc_hd__decap_3
XFILLER_35_438 VGND VGND VPWR VPWR sky130_fd_sc_hd__decap_3
XFILLER_47_287 VGND VGND VPWR VPWR sky130_fd_sc_hd__decap_3
XFILLER_62_224 VGND VGND VPWR VPWR sky130_fd_sc_hd__decap_3
XFILLER_75_585 VGND VGND VPWR VPWR sky130_fd_sc_hd__decap_3
XFILLER_90_533 VGND VGND VPWR VPWR sky130_fd_sc_hd__decap_3
XFILLER_35_449 VGND VGND VPWR VPWR sky130_fd_sc_hd__decap_3
XFILLER_62_235 VGND VGND VPWR VPWR sky130_fd_sc_hd__decap_3
XFILLER_90_566 VGND VGND VPWR VPWR sky130_fd_sc_hd__decap_3
Xclkbuf_leaf_27_clk clkload4/A VGND VGND VPWR VPWR _7392_/CLK sky130_fd_sc_hd__clkbuf_16
XFILLER_16_663 VGND VGND VPWR VPWR sky130_fd_sc_hd__decap_3
XFILLER_31_600 VGND VGND VPWR VPWR sky130_fd_sc_hd__decap_3
XFILLER_43_460 VGND VGND VPWR VPWR sky130_fd_sc_hd__decap_3
XFILLER_50_419 VGND VGND VPWR VPWR sky130_fd_sc_hd__fill_1
XFILLER_31_644 VGND VGND VPWR VPWR sky130_fd_sc_hd__decap_3
XFILLER_70_290 VGND VGND VPWR VPWR sky130_fd_sc_hd__decap_3
XFILLER_94_6 VGND VGND VPWR VPWR sky130_fd_sc_hd__decap_3
XFILLER_31_688 VGND VGND VPWR VPWR sky130_fd_sc_hd__decap_3
XFILLER_11_390 VGND VGND VPWR VPWR sky130_fd_sc_hd__fill_2
X_4530_ _4530_/A0 _4530_/A1 _4532_/S VGND VGND VPWR VPWR _7314_/D sky130_fd_sc_hd__mux2_2
XTAP_TAPCELL_ROW_96_1402 VGND VPWR sky130_fd_sc_hd__tapvpwrvgnd_1
XFILLER_7_372 VGND VGND VPWR VPWR sky130_fd_sc_hd__decap_3
XFILLER_7_383 VGND VGND VPWR VPWR sky130_fd_sc_hd__decap_3
X_7180_ _7307_/CLK _7180_/D _6460_/Y VGND VGND VPWR VPWR _7180_/Q sky130_fd_sc_hd__dfrtp_2
X_3412_ _7187_/Q _3987_/S _4278_/B1 _7379_/Q VGND VGND VPWR VPWR _3412_/X sky130_fd_sc_hd__a22o_2
X_4392_ _7369_/Q _4394_/B _4434_/B1 _7145_/Q _4391_/X VGND VGND VPWR VPWR _4392_/X
+ sky130_fd_sc_hd__a221o_2
XFILLER_98_622 VGND VGND VPWR VPWR sky130_fd_sc_hd__decap_3
XFILLER_112_421 VGND VGND VPWR VPWR sky130_fd_sc_hd__decap_3
XFILLER_97_132 VGND VGND VPWR VPWR sky130_fd_sc_hd__decap_3
XTAP_TAPCELL_ROW_5_309 VGND VPWR sky130_fd_sc_hd__tapvpwrvgnd_1
XFILLER_98_666 VGND VGND VPWR VPWR sky130_fd_sc_hd__decap_3
XFILLER_100_616 VGND VGND VPWR VPWR sky130_fd_sc_hd__decap_3
XFILLER_112_454 VGND VGND VPWR VPWR sky130_fd_sc_hd__decap_3
XFILLER_97_165 VGND VGND VPWR VPWR sky130_fd_sc_hd__decap_3
Xhold1006 _7267_/Q VGND VGND VPWR VPWR _4914_/A0 sky130_fd_sc_hd__dlygate4sd3_1
XFILLER_112_498 VGND VGND VPWR VPWR sky130_fd_sc_hd__decap_3
XFILLER_85_327 VGND VGND VPWR VPWR sky130_fd_sc_hd__fill_2
XFILLER_97_187 VGND VGND VPWR VPWR sky130_fd_sc_hd__decap_3
Xhold1017 _7262_/Q VGND VGND VPWR VPWR _4998_/A0 sky130_fd_sc_hd__dlygate4sd3_1
Xhold1028 _7038_/Q VGND VGND VPWR VPWR _5581_/A0 sky130_fd_sc_hd__dlygate4sd3_1
Xhold1039 _7332_/Q VGND VGND VPWR VPWR _4495_/A0 sky130_fd_sc_hd__dlygate4sd3_1
XFILLER_66_563 VGND VGND VPWR VPWR sky130_fd_sc_hd__decap_3
XFILLER_26_29 VGND VGND VPWR VPWR sky130_fd_sc_hd__decap_3
XFILLER_38_276 VGND VGND VPWR VPWR sky130_fd_sc_hd__decap_3
XFILLER_53_213 VGND VGND VPWR VPWR sky130_fd_sc_hd__decap_3
XFILLER_81_533 VGND VGND VPWR VPWR sky130_fd_sc_hd__decap_3
XFILLER_93_393 VGND VGND VPWR VPWR sky130_fd_sc_hd__decap_3
Xclkbuf_leaf_18_clk clkload4/A VGND VGND VPWR VPWR _7404_/CLK sky130_fd_sc_hd__clkbuf_16
X_6964_ clkload8/A _6964_/D VGND VGND VPWR VPWR _6964_/Q sky130_fd_sc_hd__dfxtp_2
XPHY_EDGE_ROW_5_Right_5 VGND VGND VPWR VPWR sky130_fd_sc_hd__decap_3
XFILLER_53_279 VGND VGND VPWR VPWR sky130_fd_sc_hd__fill_1
XFILLER_81_588 VGND VGND VPWR VPWR sky130_fd_sc_hd__decap_3
X_6895_ _6943_/CLK _6895_/D VGND VGND VPWR VPWR _6895_/Q sky130_fd_sc_hd__dfxtp_2
XFILLER_21_110 VGND VGND VPWR VPWR sky130_fd_sc_hd__fill_2
XFILLER_22_622 VGND VGND VPWR VPWR sky130_fd_sc_hd__decap_3
XFILLER_22_666 VGND VGND VPWR VPWR sky130_fd_sc_hd__decap_3
XFILLER_61_290 VGND VGND VPWR VPWR sky130_fd_sc_hd__decap_3
XFILLER_21_165 VGND VGND VPWR VPWR sky130_fd_sc_hd__decap_3
XTAP_TAPCELL_ROW_60_970 VGND VPWR sky130_fd_sc_hd__tapvpwrvgnd_1
X_4728_ _4728_/A _4728_/B VGND VGND VPWR VPWR _4729_/B sky130_fd_sc_hd__nand2_2
XFILLER_107_204 VGND VGND VPWR VPWR sky130_fd_sc_hd__decap_3
X_4659_ _4814_/A _4457_/X _4658_/Y _4852_/A _4040_/Y VGND VGND VPWR VPWR _4659_/X
+ sky130_fd_sc_hd__o2111a_2
XTAP_TAPCELL_ROW_116_1660 VGND VPWR sky130_fd_sc_hd__tapvpwrvgnd_1
XFILLER_107_21 VGND VGND VPWR VPWR sky130_fd_sc_hd__decap_3
XFILLER_1_526 VGND VGND VPWR VPWR sky130_fd_sc_hd__decap_3
XFILLER_89_600 VGND VGND VPWR VPWR sky130_fd_sc_hd__decap_3
X_7378_ _7378_/CLK _7378_/D _6658_/Y VGND VGND VPWR VPWR _7378_/Q sky130_fd_sc_hd__dfrtp_2
Xhold840 _6894_/Q VGND VGND VPWR VPWR _6894_/D sky130_fd_sc_hd__dlygate4sd3_1
Xhold851 _7071_/Q VGND VGND VPWR VPWR _7071_/D sky130_fd_sc_hd__dlygate4sd3_1
Xhold862 _7107_/Q VGND VGND VPWR VPWR _7107_/D sky130_fd_sc_hd__dlygate4sd3_1
Xhold873 _7098_/Q VGND VGND VPWR VPWR _7098_/D sky130_fd_sc_hd__dlygate4sd3_1
Xmax_cap570 _6613_/A VGND VGND VPWR VPWR _6610_/A sky130_fd_sc_hd__buf_2
XFILLER_107_54 VGND VGND VPWR VPWR sky130_fd_sc_hd__fill_2
XFILLER_115_281 VGND VGND VPWR VPWR sky130_fd_sc_hd__fill_2
XFILLER_1_559 VGND VGND VPWR VPWR sky130_fd_sc_hd__fill_1
XFILLER_67_14 VGND VGND VPWR VPWR sky130_fd_sc_hd__decap_3
XFILLER_88_121 VGND VGND VPWR VPWR sky130_fd_sc_hd__decap_3
XFILLER_89_644 VGND VGND VPWR VPWR sky130_fd_sc_hd__decap_3
Xhold884 _7096_/Q VGND VGND VPWR VPWR _7096_/D sky130_fd_sc_hd__dlygate4sd3_1
Xhold895 _7086_/Q VGND VGND VPWR VPWR _7086_/D sky130_fd_sc_hd__dlygate4sd3_1
X_6329_ _6680_/A VGND VGND VPWR VPWR _6329_/Y sky130_fd_sc_hd__inv_2
XFILLER_103_465 VGND VGND VPWR VPWR sky130_fd_sc_hd__decap_3
XFILLER_107_76 VGND VGND VPWR VPWR sky130_fd_sc_hd__fill_1
XFILLER_89_688 VGND VGND VPWR VPWR sky130_fd_sc_hd__decap_3
XFILLER_103_498 VGND VGND VPWR VPWR sky130_fd_sc_hd__decap_3
XFILLER_29_210 VGND VGND VPWR VPWR sky130_fd_sc_hd__fill_1
XFILLER_29_243 VGND VGND VPWR VPWR sky130_fd_sc_hd__fill_2
XFILLER_17_405 VGND VGND VPWR VPWR sky130_fd_sc_hd__decap_3
XFILLER_29_287 VGND VGND VPWR VPWR sky130_fd_sc_hd__decap_3
XFILLER_57_585 VGND VGND VPWR VPWR sky130_fd_sc_hd__decap_3
XFILLER_84_382 VGND VGND VPWR VPWR sky130_fd_sc_hd__fill_2
XFILLER_17_449 VGND VGND VPWR VPWR sky130_fd_sc_hd__fill_1
XFILLER_44_246 VGND VGND VPWR VPWR sky130_fd_sc_hd__decap_3
XFILLER_72_544 VGND VGND VPWR VPWR sky130_fd_sc_hd__fill_1
XTAP_TAPCELL_ROW_67_1058 VGND VPWR sky130_fd_sc_hd__tapvpwrvgnd_1
XFILLER_13_600 VGND VGND VPWR VPWR sky130_fd_sc_hd__decap_3
XFILLER_32_419 VGND VGND VPWR VPWR sky130_fd_sc_hd__fill_1
XFILLER_72_577 VGND VGND VPWR VPWR sky130_fd_sc_hd__decap_3
XFILLER_83_79 VGND VGND VPWR VPWR sky130_fd_sc_hd__decap_3
XFILLER_13_644 VGND VGND VPWR VPWR sky130_fd_sc_hd__decap_3
XTAP_TAPCELL_ROW_80_1214 VGND VPWR sky130_fd_sc_hd__tapvpwrvgnd_1
XTAP_TAPCELL_ROW_30_609 VGND VPWR sky130_fd_sc_hd__tapvpwrvgnd_1
XFILLER_9_626 VGND VGND VPWR VPWR sky130_fd_sc_hd__decap_3
XFILLER_9_615 VGND VGND VPWR VPWR sky130_fd_sc_hd__fill_1
XFILLER_12_165 VGND VGND VPWR VPWR sky130_fd_sc_hd__fill_1
XFILLER_13_688 VGND VGND VPWR VPWR sky130_fd_sc_hd__decap_3
XFILLER_9_659 VGND VGND VPWR VPWR sky130_fd_sc_hd__decap_3
XTAP_TAPCELL_ROW_10_377 VGND VPWR sky130_fd_sc_hd__tapvpwrvgnd_1
XTAP_TAPCELL_ROW_10_366 VGND VPWR sky130_fd_sc_hd__tapvpwrvgnd_1
XTAP_TAPCELL_ROW_78_1187 VGND VPWR sky130_fd_sc_hd__tapvpwrvgnd_1
XTAP_TAPCELL_ROW_91_1343 VGND VPWR sky130_fd_sc_hd__tapvpwrvgnd_1
XFILLER_67_316 VGND VGND VPWR VPWR sky130_fd_sc_hd__decap_3
XFILLER_79_154 VGND VGND VPWR VPWR sky130_fd_sc_hd__decap_3
XFILLER_95_603 VGND VGND VPWR VPWR sky130_fd_sc_hd__decap_3
XFILLER_0_592 VGND VGND VPWR VPWR sky130_fd_sc_hd__decap_3
XFILLER_94_113 VGND VGND VPWR VPWR sky130_fd_sc_hd__decap_3
XFILLER_94_124 VGND VGND VPWR VPWR sky130_fd_sc_hd__fill_2
XFILLER_95_647 VGND VGND VPWR VPWR sky130_fd_sc_hd__decap_3
XFILLER_48_541 VGND VGND VPWR VPWR sky130_fd_sc_hd__fill_1
XFILLER_94_168 VGND VGND VPWR VPWR sky130_fd_sc_hd__decap_3
XTAP_TAPCELL_ROW_38_709 VGND VPWR sky130_fd_sc_hd__tapvpwrvgnd_1
XFILLER_35_202 VGND VGND VPWR VPWR sky130_fd_sc_hd__fill_2
XFILLER_35_213 VGND VGND VPWR VPWR sky130_fd_sc_hd__decap_3
XFILLER_48_585 VGND VGND VPWR VPWR sky130_fd_sc_hd__decap_3
XFILLER_23_419 VGND VGND VPWR VPWR sky130_fd_sc_hd__decap_3
XFILLER_63_588 VGND VGND VPWR VPWR sky130_fd_sc_hd__decap_3
XTAP_TAPCELL_ROW_18_466 VGND VPWR sky130_fd_sc_hd__tapvpwrvgnd_1
XFILLER_31_430 VGND VGND VPWR VPWR sky130_fd_sc_hd__decap_3
XFILLER_31_452 VGND VGND VPWR VPWR sky130_fd_sc_hd__decap_3
XFILLER_43_290 VGND VGND VPWR VPWR sky130_fd_sc_hd__fill_1
X_6680_ _6680_/A VGND VGND VPWR VPWR _6680_/Y sky130_fd_sc_hd__inv_2
X_3892_ _6771_/Q _3892_/A2 _3892_/B1 _6765_/Q VGND VGND VPWR VPWR _3892_/X sky130_fd_sc_hd__a22o_2
XFILLER_31_485 VGND VGND VPWR VPWR sky130_fd_sc_hd__decap_3
XTAP_TAPCELL_ROW_100_1450 VGND VPWR sky130_fd_sc_hd__tapvpwrvgnd_1
XFILLER_8_681 VGND VGND VPWR VPWR sky130_fd_sc_hd__decap_3
X_7301_ _7365_/CLK _7301_/D _6581_/Y VGND VGND VPWR VPWR _7301_/Q sky130_fd_sc_hd__dfrtp_2
X_4513_ _4513_/A0 _7291_/Q _4532_/S VGND VGND VPWR VPWR _7323_/D sky130_fd_sc_hd__mux2_2
X_7232_ _7328_/CLK _7232_/D _6512_/Y VGND VGND VPWR VPWR _7232_/Q sky130_fd_sc_hd__dfrtp_2
Xclkbuf_leaf_7_clk clkload0/A VGND VGND VPWR VPWR _7378_/CLK sky130_fd_sc_hd__clkbuf_16
X_4444_ _4396_/A _4444_/B VGND VGND VPWR VPWR _4444_/X sky130_fd_sc_hd__and2b_2
X_7163_ _7355_/CLK _7163_/D _6443_/Y VGND VGND VPWR VPWR _7163_/Q sky130_fd_sc_hd__dfrtp_2
X_4375_ _5003_/A _4374_/X _4988_/A VGND VGND VPWR VPWR _4375_/X sky130_fd_sc_hd__o21ba_2
XFILLER_58_305 VGND VGND VPWR VPWR sky130_fd_sc_hd__decap_3
X_7094_ _7351_/CLK _7094_/D _6374_/Y VGND VGND VPWR VPWR _7094_/Q sky130_fd_sc_hd__dfrtp_2
X_3326_ _3326_/A _3326_/B VGND VGND VPWR VPWR _5238_/B sky130_fd_sc_hd__nor2_2
XFILLER_112_262 VGND VGND VPWR VPWR sky130_fd_sc_hd__decap_3
XFILLER_85_113 VGND VGND VPWR VPWR sky130_fd_sc_hd__decap_3
XFILLER_86_625 VGND VGND VPWR VPWR sky130_fd_sc_hd__decap_3
XFILLER_39_552 VGND VGND VPWR VPWR sky130_fd_sc_hd__decap_3
XFILLER_86_669 VGND VGND VPWR VPWR sky130_fd_sc_hd__decap_3
XFILLER_39_585 VGND VGND VPWR VPWR sky130_fd_sc_hd__decap_3
XFILLER_54_533 VGND VGND VPWR VPWR sky130_fd_sc_hd__fill_1
XFILLER_93_190 VGND VGND VPWR VPWR sky130_fd_sc_hd__decap_3
XFILLER_14_419 VGND VGND VPWR VPWR sky130_fd_sc_hd__fill_1
XFILLER_26_268 VGND VGND VPWR VPWR sky130_fd_sc_hd__fill_1
XFILLER_54_566 VGND VGND VPWR VPWR sky130_fd_sc_hd__decap_3
XFILLER_81_396 VGND VGND VPWR VPWR sky130_fd_sc_hd__decap_3
X_6947_ _6959_/CLK _6947_/D VGND VGND VPWR VPWR _6947_/Q sky130_fd_sc_hd__dfxtp_2
XFILLER_22_441 VGND VGND VPWR VPWR sky130_fd_sc_hd__decap_3
XFILLER_41_249 VGND VGND VPWR VPWR sky130_fd_sc_hd__decap_3
X_6878_ _6966_/CLK _6878_/D VGND VGND VPWR VPWR _6878_/Q sky130_fd_sc_hd__dfxtp_2
XFILLER_10_625 VGND VGND VPWR VPWR sky130_fd_sc_hd__decap_3
XFILLER_10_669 VGND VGND VPWR VPWR sky130_fd_sc_hd__decap_3
XFILLER_22_496 VGND VGND VPWR VPWR sky130_fd_sc_hd__fill_1
XFILLER_6_607 VGND VGND VPWR VPWR sky130_fd_sc_hd__decap_3
XFILLER_108_513 VGND VGND VPWR VPWR sky130_fd_sc_hd__decap_3
XFILLER_108_557 VGND VGND VPWR VPWR sky130_fd_sc_hd__decap_3
XTAP_TAPCELL_ROW_114_1619 VGND VPWR sky130_fd_sc_hd__tapvpwrvgnd_1
XFILLER_78_24 VGND VGND VPWR VPWR sky130_fd_sc_hd__decap_3
XFILLER_89_430 VGND VGND VPWR VPWR sky130_fd_sc_hd__decap_3
Xhold670 _6756_/Q VGND VGND VPWR VPWR _6756_/D sky130_fd_sc_hd__dlygate4sd3_1
Xhold681 _6951_/Q VGND VGND VPWR VPWR _6951_/D sky130_fd_sc_hd__dlygate4sd3_1
XFILLER_103_240 VGND VGND VPWR VPWR sky130_fd_sc_hd__fill_1
XFILLER_77_603 VGND VGND VPWR VPWR sky130_fd_sc_hd__decap_3
XFILLER_78_79 VGND VGND VPWR VPWR sky130_fd_sc_hd__decap_3
Xhold692 _6964_/Q VGND VGND VPWR VPWR _6964_/D sky130_fd_sc_hd__dlygate4sd3_1
XFILLER_103_262 VGND VGND VPWR VPWR sky130_fd_sc_hd__fill_2
XFILLER_103_284 VGND VGND VPWR VPWR sky130_fd_sc_hd__decap_3
XFILLER_77_647 VGND VGND VPWR VPWR sky130_fd_sc_hd__decap_3
XFILLER_49_349 VGND VGND VPWR VPWR sky130_fd_sc_hd__decap_3
XFILLER_94_12 VGND VGND VPWR VPWR sky130_fd_sc_hd__decap_3
XFILLER_45_511 VGND VGND VPWR VPWR sky130_fd_sc_hd__fill_1
XFILLER_91_116 VGND VGND VPWR VPWR sky130_fd_sc_hd__decap_3
XFILLER_92_628 VGND VGND VPWR VPWR sky130_fd_sc_hd__decap_3
XFILLER_17_246 VGND VGND VPWR VPWR sky130_fd_sc_hd__decap_3
XFILLER_45_533 VGND VGND VPWR VPWR sky130_fd_sc_hd__fill_1
XFILLER_45_555 VGND VGND VPWR VPWR sky130_fd_sc_hd__decap_3
XFILLER_72_330 VGND VGND VPWR VPWR sky130_fd_sc_hd__decap_3
XFILLER_17_268 VGND VGND VPWR VPWR sky130_fd_sc_hd__decap_3
XFILLER_17_279 VGND VGND VPWR VPWR sky130_fd_sc_hd__fill_1
XFILLER_45_588 VGND VGND VPWR VPWR sky130_fd_sc_hd__decap_3
XFILLER_60_525 VGND VGND VPWR VPWR sky130_fd_sc_hd__fill_2
XFILLER_13_452 VGND VGND VPWR VPWR sky130_fd_sc_hd__decap_3
XFILLER_60_558 VGND VGND VPWR VPWR sky130_fd_sc_hd__decap_3
XTAP_TAPCELL_ROW_43_767 VGND VPWR sky130_fd_sc_hd__tapvpwrvgnd_1
XTAP_TAPCELL_ROW_15_436 VGND VPWR sky130_fd_sc_hd__tapvpwrvgnd_1
XFILLER_13_485 VGND VGND VPWR VPWR sky130_fd_sc_hd__fill_1
XFILLER_40_271 VGND VGND VPWR VPWR sky130_fd_sc_hd__decap_3
XFILLER_9_423 VGND VGND VPWR VPWR sky130_fd_sc_hd__fill_1
XFILLER_9_489 VGND VGND VPWR VPWR sky130_fd_sc_hd__decap_3
XFILLER_114_516 VGND VGND VPWR VPWR sky130_fd_sc_hd__decap_3
XFILLER_5_662 VGND VGND VPWR VPWR sky130_fd_sc_hd__decap_3
XFILLER_5_673 VGND VGND VPWR VPWR sky130_fd_sc_hd__decap_3
XFILLER_4_161 VGND VGND VPWR VPWR sky130_fd_sc_hd__decap_3
XFILLER_4_194 VGND VGND VPWR VPWR sky130_fd_sc_hd__fill_2
XFILLER_95_400 VGND VGND VPWR VPWR sky130_fd_sc_hd__decap_3
X_4160_ _7297_/Q _4491_/S _4348_/A2 _7169_/Q _4159_/X VGND VGND VPWR VPWR _4160_/X
+ sky130_fd_sc_hd__a221o_2
XFILLER_68_625 VGND VGND VPWR VPWR sky130_fd_sc_hd__decap_3
XFILLER_67_135 VGND VGND VPWR VPWR sky130_fd_sc_hd__decap_3
XFILLER_67_157 VGND VGND VPWR VPWR sky130_fd_sc_hd__decap_3
XFILLER_68_669 VGND VGND VPWR VPWR sky130_fd_sc_hd__decap_3
XFILLER_83_606 VGND VGND VPWR VPWR sky130_fd_sc_hd__decap_3
X_4091_ _7110_/Q _4351_/A2 _4434_/B1 _7142_/Q _4090_/X VGND VGND VPWR VPWR _4091_/X
+ sky130_fd_sc_hd__a221o_2
XFILLER_48_360 VGND VGND VPWR VPWR sky130_fd_sc_hd__decap_3
XFILLER_82_105 VGND VGND VPWR VPWR sky130_fd_sc_hd__decap_3
XFILLER_83_617 VGND VGND VPWR VPWR sky130_fd_sc_hd__decap_3
XFILLER_36_533 VGND VGND VPWR VPWR sky130_fd_sc_hd__decap_3
XFILLER_63_330 VGND VGND VPWR VPWR sky130_fd_sc_hd__decap_3
XFILLER_82_138 VGND VGND VPWR VPWR sky130_fd_sc_hd__fill_2
XFILLER_36_566 VGND VGND VPWR VPWR sky130_fd_sc_hd__decap_3
XFILLER_51_503 VGND VGND VPWR VPWR sky130_fd_sc_hd__fill_1
XFILLER_51_514 VGND VGND VPWR VPWR sky130_fd_sc_hd__fill_1
XFILLER_63_363 VGND VGND VPWR VPWR sky130_fd_sc_hd__decap_3
XFILLER_91_650 VGND VGND VPWR VPWR sky130_fd_sc_hd__decap_3
Xplace330 _3590_/A VGND VGND VPWR VPWR _4460_/A sky130_fd_sc_hd__buf_2
X_6801_ _6941_/CLK _6801_/D VGND VGND VPWR VPWR _6801_/Q sky130_fd_sc_hd__dfxtp_2
XFILLER_51_536 VGND VGND VPWR VPWR sky130_fd_sc_hd__decap_3
XFILLER_90_171 VGND VGND VPWR VPWR sky130_fd_sc_hd__decap_3
Xplace363 _4267_/B1 VGND VGND VPWR VPWR _4436_/B1 sky130_fd_sc_hd__buf_2
Xplace352 _3449_/X VGND VGND VPWR VPWR _4337_/B sky130_fd_sc_hd__buf_2
Xplace341 _3377_/X VGND VGND VPWR VPWR _4349_/B1 sky130_fd_sc_hd__buf_2
X_4993_ _4987_/A _4991_/Y _4992_/Y VGND VGND VPWR VPWR _4993_/X sky130_fd_sc_hd__o21a_2
Xplace374 _5151_/A VGND VGND VPWR VPWR _3904_/A sky130_fd_sc_hd__buf_2
Xplace385 _3334_/Y VGND VGND VPWR VPWR _3339_/C1 sky130_fd_sc_hd__buf_2
Xplace396 _5354_/S VGND VGND VPWR VPWR _5340_/S sky130_fd_sc_hd__buf_2
X_6732_ clkload9/A _6732_/D VGND VGND VPWR VPWR _6732_/Q sky130_fd_sc_hd__dfxtp_2
X_6663_ _6663_/A VGND VGND VPWR VPWR _6663_/Y sky130_fd_sc_hd__inv_2
X_3875_ _3875_/A1 _5151_/A _3874_/X VGND VGND VPWR VPWR _7383_/D sky130_fd_sc_hd__o21a_2
X_6594_ _6635_/A VGND VGND VPWR VPWR _6594_/Y sky130_fd_sc_hd__inv_2
XFILLER_105_505 VGND VGND VPWR VPWR sky130_fd_sc_hd__decap_3
XFILLER_105_538 VGND VGND VPWR VPWR sky130_fd_sc_hd__decap_3
X_7215_ clkload8/A _7215_/D _6495_/Y VGND VGND VPWR VPWR _7215_/Q sky130_fd_sc_hd__dfrtp_2
XFILLER_59_603 VGND VGND VPWR VPWR sky130_fd_sc_hd__decap_3
X_7146_ _7406_/CLK _7146_/D _6426_/Y VGND VGND VPWR VPWR _7146_/Q sky130_fd_sc_hd__dfrtp_2
XFILLER_113_582 VGND VGND VPWR VPWR sky130_fd_sc_hd__decap_3
XFILLER_58_124 VGND VGND VPWR VPWR sky130_fd_sc_hd__decap_3
XFILLER_59_647 VGND VGND VPWR VPWR sky130_fd_sc_hd__decap_3
XFILLER_86_433 VGND VGND VPWR VPWR sky130_fd_sc_hd__fill_1
X_4358_ _4367_/A _4367_/B _4367_/C VGND VGND VPWR VPWR _5072_/B sky130_fd_sc_hd__a21bo_2
X_7077_ _7406_/CLK _7077_/D _6357_/Y VGND VGND VPWR VPWR _7077_/Q sky130_fd_sc_hd__dfrtp_2
X_4289_ _4289_/A _5699_/S VGND VGND VPWR VPWR _4649_/A sky130_fd_sc_hd__nand2_2
X_3309_ _6981_/Q _3365_/A _3331_/B VGND VGND VPWR VPWR _3383_/B sky130_fd_sc_hd__or3_4
XFILLER_74_628 VGND VGND VPWR VPWR sky130_fd_sc_hd__decap_3
XFILLER_27_544 VGND VGND VPWR VPWR sky130_fd_sc_hd__decap_3
XFILLER_54_330 VGND VGND VPWR VPWR sky130_fd_sc_hd__decap_3
XFILLER_64_26 VGND VGND VPWR VPWR sky130_fd_sc_hd__fill_2
XFILLER_82_672 VGND VGND VPWR VPWR sky130_fd_sc_hd__decap_3
XFILLER_27_588 VGND VGND VPWR VPWR sky130_fd_sc_hd__decap_3
XTAP_TAPCELL_ROW_64_1017 VGND VPWR sky130_fd_sc_hd__tapvpwrvgnd_1
XFILLER_14_249 VGND VGND VPWR VPWR sky130_fd_sc_hd__decap_3
XFILLER_42_569 VGND VGND VPWR VPWR sky130_fd_sc_hd__decap_3
XFILLER_81_193 VGND VGND VPWR VPWR sky130_fd_sc_hd__decap_3
Xfanout20 _6678_/A VGND VGND VPWR VPWR _6667_/A sky130_fd_sc_hd__clkdlybuf4s25_1
Xfanout31 fanout33/X VGND VGND VPWR VPWR _6567_/A sky130_fd_sc_hd__buf_1
XFILLER_10_411 VGND VGND VPWR VPWR sky130_fd_sc_hd__decap_3
Xfanout42 fanout46/X VGND VGND VPWR VPWR _6638_/A sky130_fd_sc_hd__buf_2
Xfanout53 _6645_/A VGND VGND VPWR VPWR _6642_/A sky130_fd_sc_hd__buf_2
Xfanout64 _6350_/A VGND VGND VPWR VPWR _6582_/A sky130_fd_sc_hd__clkdlybuf4s25_1
XTAP_TAPCELL_ROW_40_726 VGND VPWR sky130_fd_sc_hd__tapvpwrvgnd_1
XFILLER_22_282 VGND VGND VPWR VPWR sky130_fd_sc_hd__decap_3
XFILLER_80_58 VGND VGND VPWR VPWR sky130_fd_sc_hd__decap_3
XTAP_TAPCELL_ROW_40_737 VGND VPWR sky130_fd_sc_hd__tapvpwrvgnd_1
XFILLER_10_466 VGND VGND VPWR VPWR sky130_fd_sc_hd__decap_3
XFILLER_10_477 VGND VGND VPWR VPWR sky130_fd_sc_hd__decap_3
XFILLER_89_12 VGND VGND VPWR VPWR sky130_fd_sc_hd__decap_3
XFILLER_108_365 VGND VGND VPWR VPWR sky130_fd_sc_hd__decap_3
XTAP_TAPCELL_ROW_20_494 VGND VPWR sky130_fd_sc_hd__tapvpwrvgnd_1
XFILLER_2_610 VGND VGND VPWR VPWR sky130_fd_sc_hd__decap_3
XTAP_TAPCELL_ROW_75_1157 VGND VPWR sky130_fd_sc_hd__tapvpwrvgnd_1
XTAP_TAPCELL_ROW_75_1146 VGND VPWR sky130_fd_sc_hd__tapvpwrvgnd_1
XFILLER_111_508 VGND VGND VPWR VPWR sky130_fd_sc_hd__decap_3
XFILLER_1_142 VGND VGND VPWR VPWR sky130_fd_sc_hd__decap_3
XFILLER_2_643 VGND VGND VPWR VPWR sky130_fd_sc_hd__fill_1
XFILLER_2_654 VGND VGND VPWR VPWR sky130_fd_sc_hd__decap_3
XFILLER_96_208 VGND VGND VPWR VPWR sky130_fd_sc_hd__decap_3
XFILLER_104_560 VGND VGND VPWR VPWR sky130_fd_sc_hd__decap_3
XFILLER_1_186 VGND VGND VPWR VPWR sky130_fd_sc_hd__fill_1
XFILLER_2_687 VGND VGND VPWR VPWR sky130_fd_sc_hd__decap_3
XFILLER_49_113 VGND VGND VPWR VPWR sky130_fd_sc_hd__fill_1
XFILLER_49_146 VGND VGND VPWR VPWR sky130_fd_sc_hd__decap_3
XFILLER_49_157 VGND VGND VPWR VPWR sky130_fd_sc_hd__decap_3
XFILLER_65_606 VGND VGND VPWR VPWR sky130_fd_sc_hd__decap_3
XFILLER_77_444 VGND VGND VPWR VPWR sky130_fd_sc_hd__decap_3
XFILLER_38_71 VGND VGND VPWR VPWR sky130_fd_sc_hd__decap_3
XFILLER_49_179 VGND VGND VPWR VPWR sky130_fd_sc_hd__decap_3
XFILLER_65_617 VGND VGND VPWR VPWR sky130_fd_sc_hd__decap_3
XFILLER_77_477 VGND VGND VPWR VPWR sky130_fd_sc_hd__decap_3
XFILLER_92_403 VGND VGND VPWR VPWR sky130_fd_sc_hd__decap_3
XTAP_TAPCELL_ROW_48_826 VGND VPWR sky130_fd_sc_hd__tapvpwrvgnd_1
XFILLER_18_533 VGND VGND VPWR VPWR sky130_fd_sc_hd__decap_3
XFILLER_64_149 VGND VGND VPWR VPWR sky130_fd_sc_hd__decap_3
XFILLER_92_436 VGND VGND VPWR VPWR sky130_fd_sc_hd__decap_3
XFILLER_92_447 VGND VGND VPWR VPWR sky130_fd_sc_hd__fill_2
XFILLER_92_458 VGND VGND VPWR VPWR sky130_fd_sc_hd__decap_3
XFILLER_18_566 VGND VGND VPWR VPWR sky130_fd_sc_hd__decap_3
XFILLER_33_503 VGND VGND VPWR VPWR sky130_fd_sc_hd__fill_1
XFILLER_73_650 VGND VGND VPWR VPWR sky130_fd_sc_hd__decap_3
XFILLER_45_385 VGND VGND VPWR VPWR sky130_fd_sc_hd__decap_3
XFILLER_60_300 VGND VGND VPWR VPWR sky130_fd_sc_hd__decap_3
XTAP_TAPCELL_ROW_86_1286 VGND VPWR sky130_fd_sc_hd__tapvpwrvgnd_1
XTAP_TAPCELL_ROW_28_583 VGND VPWR sky130_fd_sc_hd__tapvpwrvgnd_1
XFILLER_33_547 VGND VGND VPWR VPWR sky130_fd_sc_hd__fill_1
XFILLER_20_208 VGND VGND VPWR VPWR sky130_fd_sc_hd__decap_3
XFILLER_60_388 VGND VGND VPWR VPWR sky130_fd_sc_hd__decap_3
XFILLER_41_591 VGND VGND VPWR VPWR sky130_fd_sc_hd__decap_3
XFILLER_9_242 VGND VGND VPWR VPWR sky130_fd_sc_hd__decap_3
XFILLER_9_231 VGND VGND VPWR VPWR sky130_fd_sc_hd__decap_3
Xclkload12 _7378_/CLK VGND VGND VPWR VPWR clkload12/X sky130_fd_sc_hd__clkbuf_8
Xclkload23 _6943_/CLK VGND VGND VPWR VPWR clkload23/X sky130_fd_sc_hd__clkbuf_1
Xclkload34 _7365_/CLK VGND VGND VPWR VPWR clkload34/X sky130_fd_sc_hd__clkbuf_1
X_3591_ _3591_/A _3591_/B _3591_/C _3586_/D VGND VGND VPWR VPWR _3591_/Y sky130_fd_sc_hd__nor4b_2
XFILLER_55_3 VGND VGND VPWR VPWR sky130_fd_sc_hd__decap_3
XFILLER_102_519 VGND VGND VPWR VPWR sky130_fd_sc_hd__decap_3
X_7000_ _7144_/CLK _7000_/D _6280_/Y VGND VGND VPWR VPWR _7000_/Q sky130_fd_sc_hd__dfrtp_2
X_4212_ _7324_/Q _3968_/S _4420_/B1 _7132_/Q VGND VGND VPWR VPWR _4212_/X sky130_fd_sc_hd__a22o_2
X_5192_ _5192_/A _5209_/B VGND VGND VPWR VPWR _7232_/D sky130_fd_sc_hd__and2_2
XFILLER_68_433 VGND VGND VPWR VPWR sky130_fd_sc_hd__decap_3
X_4143_ _4845_/A _4140_/X _4142_/X VGND VGND VPWR VPWR _4143_/X sky130_fd_sc_hd__a21o_2
XFILLER_110_563 VGND VGND VPWR VPWR sky130_fd_sc_hd__decap_3
XFILLER_56_628 VGND VGND VPWR VPWR sky130_fd_sc_hd__decap_3
XFILLER_68_488 VGND VGND VPWR VPWR sky130_fd_sc_hd__decap_3
XFILLER_83_425 VGND VGND VPWR VPWR sky130_fd_sc_hd__decap_3
XFILLER_95_274 VGND VGND VPWR VPWR sky130_fd_sc_hd__decap_3
X_4074_ _7083_/Q _4102_/B _4432_/B1 _4073_/X VGND VGND VPWR VPWR _4451_/A sky130_fd_sc_hd__o211ai_2
XFILLER_55_127 VGND VGND VPWR VPWR sky130_fd_sc_hd__fill_2
XFILLER_36_330 VGND VGND VPWR VPWR sky130_fd_sc_hd__decap_3
XFILLER_36_363 VGND VGND VPWR VPWR sky130_fd_sc_hd__fill_1
XFILLER_64_672 VGND VGND VPWR VPWR sky130_fd_sc_hd__decap_3
XFILLER_71_609 VGND VGND VPWR VPWR sky130_fd_sc_hd__decap_3
XFILLER_83_469 VGND VGND VPWR VPWR sky130_fd_sc_hd__decap_3
XFILLER_24_536 VGND VGND VPWR VPWR sky130_fd_sc_hd__decap_3
XFILLER_51_322 VGND VGND VPWR VPWR sky130_fd_sc_hd__decap_3
XFILLER_91_480 VGND VGND VPWR VPWR sky130_fd_sc_hd__decap_3
XFILLER_24_569 VGND VGND VPWR VPWR sky130_fd_sc_hd__decap_3
XFILLER_63_193 VGND VGND VPWR VPWR sky130_fd_sc_hd__decap_3
XFILLER_51_388 VGND VGND VPWR VPWR sky130_fd_sc_hd__decap_3
X_6715_ _7403_/CLK _6715_/D VGND VGND VPWR VPWR _6715_/Q sky130_fd_sc_hd__dfxtp_2
X_4976_ _6992_/Q _5001_/A _6993_/Q VGND VGND VPWR VPWR _4977_/B sky130_fd_sc_hd__a21oi_2
X_3927_ _3682_/A _3926_/X _4791_/A1 VGND VGND VPWR VPWR _3927_/X sky130_fd_sc_hd__a21o_2
Xclkload6 clkload6/A VGND VGND VPWR VPWR clkload6/Y sky130_fd_sc_hd__clkinv_2
X_6646_ _6653_/A VGND VGND VPWR VPWR _6646_/Y sky130_fd_sc_hd__inv_2
X_3858_ _6698_/Q _3925_/A2 _3925_/B1 _6876_/Q VGND VGND VPWR VPWR _3858_/X sky130_fd_sc_hd__a22o_2
X_6577_ _6613_/A VGND VGND VPWR VPWR _6577_/Y sky130_fd_sc_hd__inv_2
X_3789_ _3728_/Y _3781_/X _3783_/X _3725_/X _3788_/X VGND VGND VPWR VPWR _3789_/X
+ sky130_fd_sc_hd__a221o_2
XFILLER_105_335 VGND VGND VPWR VPWR sky130_fd_sc_hd__fill_1
XFILLER_105_368 VGND VGND VPWR VPWR sky130_fd_sc_hd__fill_2
XFILLER_105_379 VGND VGND VPWR VPWR sky130_fd_sc_hd__fill_2
XFILLER_115_21 VGND VGND VPWR VPWR sky130_fd_sc_hd__decap_3
XFILLER_99_591 VGND VGND VPWR VPWR sky130_fd_sc_hd__decap_3
XFILLER_101_541 VGND VGND VPWR VPWR sky130_fd_sc_hd__decap_3
XFILLER_113_390 VGND VGND VPWR VPWR sky130_fd_sc_hd__fill_2
XFILLER_115_54 VGND VGND VPWR VPWR sky130_fd_sc_hd__fill_2
XFILLER_59_444 VGND VGND VPWR VPWR sky130_fd_sc_hd__decap_3
XFILLER_59_455 VGND VGND VPWR VPWR sky130_fd_sc_hd__decap_3
X_7129_ _7353_/CLK _7129_/D _6409_/Y VGND VGND VPWR VPWR _7129_/Q sky130_fd_sc_hd__dfrtp_2
XFILLER_101_585 VGND VGND VPWR VPWR sky130_fd_sc_hd__decap_3
XFILLER_115_87 VGND VGND VPWR VPWR sky130_fd_sc_hd__decap_3
XFILLER_19_308 VGND VGND VPWR VPWR sky130_fd_sc_hd__decap_3
XFILLER_47_606 VGND VGND VPWR VPWR sky130_fd_sc_hd__decap_3
XFILLER_47_617 VGND VGND VPWR VPWR sky130_fd_sc_hd__decap_3
XFILLER_59_466 VGND VGND VPWR VPWR sky130_fd_sc_hd__fill_2
XTAP_TAPCELL_ROW_70_1087 VGND VPWR sky130_fd_sc_hd__tapvpwrvgnd_1
XFILLER_46_138 VGND VGND VPWR VPWR sky130_fd_sc_hd__fill_2
XFILLER_55_650 VGND VGND VPWR VPWR sky130_fd_sc_hd__decap_3
XFILLER_15_514 VGND VGND VPWR VPWR sky130_fd_sc_hd__decap_3
XFILLER_27_396 VGND VGND VPWR VPWR sky130_fd_sc_hd__decap_3
XFILLER_42_300 VGND VGND VPWR VPWR sky130_fd_sc_hd__decap_3
XFILLER_15_547 VGND VGND VPWR VPWR sky130_fd_sc_hd__decap_3
XFILLER_42_322 VGND VGND VPWR VPWR sky130_fd_sc_hd__decap_3
XFILLER_70_631 VGND VGND VPWR VPWR sky130_fd_sc_hd__decap_3
XFILLER_82_491 VGND VGND VPWR VPWR sky130_fd_sc_hd__decap_3
XFILLER_30_528 VGND VGND VPWR VPWR sky130_fd_sc_hd__decap_3
XFILLER_70_675 VGND VGND VPWR VPWR sky130_fd_sc_hd__decap_3
XTAP_TAPCELL_ROW_53_884 VGND VPWR sky130_fd_sc_hd__tapvpwrvgnd_1
XTAP_TAPCELL_ROW_25_553 VGND VPWR sky130_fd_sc_hd__tapvpwrvgnd_1
XFILLER_23_591 VGND VGND VPWR VPWR sky130_fd_sc_hd__decap_3
XFILLER_10_230 VGND VGND VPWR VPWR sky130_fd_sc_hd__fill_2
XFILLER_109_641 VGND VGND VPWR VPWR sky130_fd_sc_hd__decap_3
XFILLER_10_274 VGND VGND VPWR VPWR sky130_fd_sc_hd__decap_3
XFILLER_6_223 VGND VGND VPWR VPWR sky130_fd_sc_hd__decap_3
XFILLER_109_685 VGND VGND VPWR VPWR sky130_fd_sc_hd__decap_3
XFILLER_6_245 VGND VGND VPWR VPWR sky130_fd_sc_hd__decap_3
XFILLER_108_195 VGND VGND VPWR VPWR sky130_fd_sc_hd__fill_1
XFILLER_40_83 VGND VGND VPWR VPWR sky130_fd_sc_hd__fill_1
XFILLER_69_208 VGND VGND VPWR VPWR sky130_fd_sc_hd__decap_3
XFILLER_97_517 VGND VGND VPWR VPWR sky130_fd_sc_hd__decap_3
XFILLER_111_327 VGND VGND VPWR VPWR sky130_fd_sc_hd__decap_3
XFILLER_2_473 VGND VGND VPWR VPWR sky130_fd_sc_hd__decap_3
XFILLER_2_495 VGND VGND VPWR VPWR sky130_fd_sc_hd__decap_3
XFILLER_38_628 VGND VGND VPWR VPWR sky130_fd_sc_hd__decap_3
XFILLER_65_414 VGND VGND VPWR VPWR sky130_fd_sc_hd__decap_3
XFILLER_77_274 VGND VGND VPWR VPWR sky130_fd_sc_hd__decap_3
XFILLER_92_200 VGND VGND VPWR VPWR sky130_fd_sc_hd__decap_3
XTAP_TAPCELL_ROW_88_1304 VGND VPWR sky130_fd_sc_hd__tapvpwrvgnd_1
XFILLER_53_609 VGND VGND VPWR VPWR sky130_fd_sc_hd__decap_3
XFILLER_65_458 VGND VGND VPWR VPWR sky130_fd_sc_hd__decap_3
XFILLER_18_374 VGND VGND VPWR VPWR sky130_fd_sc_hd__decap_3
XFILLER_46_672 VGND VGND VPWR VPWR sky130_fd_sc_hd__decap_3
XFILLER_61_620 VGND VGND VPWR VPWR sky130_fd_sc_hd__decap_3
XFILLER_92_299 VGND VGND VPWR VPWR sky130_fd_sc_hd__decap_3
XFILLER_45_193 VGND VGND VPWR VPWR sky130_fd_sc_hd__decap_3
XFILLER_61_653 VGND VGND VPWR VPWR sky130_fd_sc_hd__decap_3
X_4830_ _4646_/Y _4827_/A _4829_/Y VGND VGND VPWR VPWR _4830_/X sky130_fd_sc_hd__o21a_2
XFILLER_33_366 VGND VGND VPWR VPWR sky130_fd_sc_hd__decap_3
XFILLER_60_141 VGND VGND VPWR VPWR sky130_fd_sc_hd__fill_2
XFILLER_60_152 VGND VGND VPWR VPWR sky130_fd_sc_hd__decap_3
X_4761_ _4762_/B _4761_/B _4761_/C VGND VGND VPWR VPWR _4761_/Y sky130_fd_sc_hd__nand3_2
X_6500_ _6596_/A VGND VGND VPWR VPWR _6500_/Y sky130_fd_sc_hd__inv_2
X_4692_ _7006_/Q _4749_/B VGND VGND VPWR VPWR _4750_/B sky130_fd_sc_hd__and2_2
X_3712_ _3746_/B VGND VGND VPWR VPWR _3741_/B sky130_fd_sc_hd__inv_2
XTAP_TAPCELL_ROW_99_1444 VGND VPWR sky130_fd_sc_hd__tapvpwrvgnd_1
X_6431_ _6625_/A VGND VGND VPWR VPWR _6431_/Y sky130_fd_sc_hd__inv_2
XFILLER_115_600 VGND VGND VPWR VPWR sky130_fd_sc_hd__decap_3
X_6362_ _6364_/A VGND VGND VPWR VPWR _6362_/Y sky130_fd_sc_hd__inv_2
XFILLER_115_644 VGND VGND VPWR VPWR sky130_fd_sc_hd__decap_3
X_3574_ _7348_/Q _4278_/B1 _3573_/X _3556_/A VGND VGND VPWR VPWR _3574_/X sky130_fd_sc_hd__a211o_2
XFILLER_114_132 VGND VGND VPWR VPWR sky130_fd_sc_hd__decap_3
X_6293_ _6602_/A VGND VGND VPWR VPWR _6293_/Y sky130_fd_sc_hd__inv_2
XFILLER_114_187 VGND VGND VPWR VPWR sky130_fd_sc_hd__decap_3
XFILLER_115_688 VGND VGND VPWR VPWR sky130_fd_sc_hd__decap_3
XFILLER_88_528 VGND VGND VPWR VPWR sky130_fd_sc_hd__decap_3
XFILLER_88_539 VGND VGND VPWR VPWR sky130_fd_sc_hd__decap_3
X_5175_ _5175_/A _5190_/B VGND VGND VPWR VPWR _7240_/D sky130_fd_sc_hd__and2_2
XFILLER_29_606 VGND VGND VPWR VPWR sky130_fd_sc_hd__decap_3
XFILLER_29_617 VGND VGND VPWR VPWR sky130_fd_sc_hd__decap_3
XFILLER_96_572 VGND VGND VPWR VPWR sky130_fd_sc_hd__decap_3
X_4126_ _4126_/A _4125_/X VGND VGND VPWR VPWR _4890_/B sky130_fd_sc_hd__or2b_2
XFILLER_110_371 VGND VGND VPWR VPWR sky130_fd_sc_hd__fill_2
XFILLER_56_447 VGND VGND VPWR VPWR sky130_fd_sc_hd__decap_3
XFILLER_37_650 VGND VGND VPWR VPWR sky130_fd_sc_hd__decap_3
X_4057_ _7308_/Q _4478_/S _4437_/B1 _7372_/Q _4429_/C1 VGND VGND VPWR VPWR _4057_/X
+ sky130_fd_sc_hd__a221o_2
XFILLER_64_480 VGND VGND VPWR VPWR sky130_fd_sc_hd__fill_1
XTAP_TAPCELL_ROW_108_1551 VGND VPWR sky130_fd_sc_hd__tapvpwrvgnd_1
XFILLER_101_12 VGND VGND VPWR VPWR sky130_fd_sc_hd__decap_3
XFILLER_24_344 VGND VGND VPWR VPWR sky130_fd_sc_hd__decap_3
XFILLER_52_631 VGND VGND VPWR VPWR sky130_fd_sc_hd__decap_3
XFILLER_101_45 VGND VGND VPWR VPWR sky130_fd_sc_hd__fill_2
XFILLER_52_675 VGND VGND VPWR VPWR sky130_fd_sc_hd__decap_3
XFILLER_12_539 VGND VGND VPWR VPWR sky130_fd_sc_hd__decap_3
XFILLER_61_27 VGND VGND VPWR VPWR sky130_fd_sc_hd__decap_3
X_4959_ _6993_/Q _4958_/Y _6994_/Q VGND VGND VPWR VPWR _4960_/C sky130_fd_sc_hd__a21oi_2
XTAP_TAPCELL_ROW_22_512 VGND VPWR sky130_fd_sc_hd__tapvpwrvgnd_1
XTAP_TAPCELL_ROW_50_854 VGND VPWR sky130_fd_sc_hd__tapvpwrvgnd_1
XFILLER_20_572 VGND VGND VPWR VPWR sky130_fd_sc_hd__decap_3
X_6629_ _6629_/A VGND VGND VPWR VPWR _6629_/Y sky130_fd_sc_hd__inv_2
XFILLER_105_110 VGND VGND VPWR VPWR sky130_fd_sc_hd__fill_2
XFILLER_106_622 VGND VGND VPWR VPWR sky130_fd_sc_hd__decap_3
XFILLER_106_666 VGND VGND VPWR VPWR sky130_fd_sc_hd__decap_3
XTAP_TAPCELL_ROW_72_1116 VGND VPWR sky130_fd_sc_hd__tapvpwrvgnd_1
XFILLER_79_539 VGND VGND VPWR VPWR sky130_fd_sc_hd__decap_3
XFILLER_86_46 VGND VGND VPWR VPWR sky130_fd_sc_hd__fill_2
XFILLER_94_509 VGND VGND VPWR VPWR sky130_fd_sc_hd__decap_3
XFILLER_87_561 VGND VGND VPWR VPWR sky130_fd_sc_hd__decap_3
XFILLER_19_116 VGND VGND VPWR VPWR sky130_fd_sc_hd__decap_3
XFILLER_59_296 VGND VGND VPWR VPWR sky130_fd_sc_hd__decap_3
XFILLER_74_200 VGND VGND VPWR VPWR sky130_fd_sc_hd__decap_3
XFILLER_87_594 VGND VGND VPWR VPWR sky130_fd_sc_hd__decap_3
XTAP_TAPCELL_ROW_58_943 VGND VPWR sky130_fd_sc_hd__tapvpwrvgnd_1
XFILLER_35_609 VGND VGND VPWR VPWR sky130_fd_sc_hd__decap_3
XFILLER_62_406 VGND VGND VPWR VPWR sky130_fd_sc_hd__decap_3
XFILLER_28_672 VGND VGND VPWR VPWR sky130_fd_sc_hd__decap_3
XFILLER_43_620 VGND VGND VPWR VPWR sky130_fd_sc_hd__decap_3
XFILLER_62_439 VGND VGND VPWR VPWR sky130_fd_sc_hd__decap_3
XFILLER_74_277 VGND VGND VPWR VPWR sky130_fd_sc_hd__decap_3
XTAP_TAPCELL_ROW_2_281 VGND VPWR sky130_fd_sc_hd__tapvpwrvgnd_1
XTAP_TAPCELL_ROW_2_270 VGND VPWR sky130_fd_sc_hd__tapvpwrvgnd_1
XFILLER_43_653 VGND VGND VPWR VPWR sky130_fd_sc_hd__decap_3
XTAP_TAPCELL_ROW_83_1245 VGND VPWR sky130_fd_sc_hd__tapvpwrvgnd_1
XFILLER_70_450 VGND VGND VPWR VPWR sky130_fd_sc_hd__fill_1
XFILLER_70_472 VGND VGND VPWR VPWR sky130_fd_sc_hd__decap_3
XFILLER_70_494 VGND VGND VPWR VPWR sky130_fd_sc_hd__decap_3
XFILLER_11_550 VGND VGND VPWR VPWR sky130_fd_sc_hd__decap_3
XFILLER_89_9 VGND VGND VPWR VPWR sky130_fd_sc_hd__decap_3
XFILLER_11_561 VGND VGND VPWR VPWR sky130_fd_sc_hd__decap_3
XFILLER_11_594 VGND VGND VPWR VPWR sky130_fd_sc_hd__decap_3
XFILLER_51_60 VGND VGND VPWR VPWR sky130_fd_sc_hd__decap_3
XFILLER_7_532 VGND VGND VPWR VPWR sky130_fd_sc_hd__decap_3
XFILLER_51_93 VGND VGND VPWR VPWR sky130_fd_sc_hd__decap_3
XFILLER_7_576 VGND VGND VPWR VPWR sky130_fd_sc_hd__decap_3
XFILLER_109_482 VGND VGND VPWR VPWR sky130_fd_sc_hd__decap_3
XTAP_TAPCELL_ROW_94_1374 VGND VPWR sky130_fd_sc_hd__tapvpwrvgnd_1
XFILLER_112_625 VGND VGND VPWR VPWR sky130_fd_sc_hd__decap_3
XFILLER_97_325 VGND VGND VPWR VPWR sky130_fd_sc_hd__decap_3
XTAP_TAPCELL_ROW_94_1385 VGND VPWR sky130_fd_sc_hd__tapvpwrvgnd_1
XFILLER_112_669 VGND VGND VPWR VPWR sky130_fd_sc_hd__decap_3
XFILLER_2_281 VGND VGND VPWR VPWR sky130_fd_sc_hd__fill_1
XFILLER_38_403 VGND VGND VPWR VPWR sky130_fd_sc_hd__decap_3
XFILLER_78_572 VGND VGND VPWR VPWR sky130_fd_sc_hd__decap_3
XFILLER_18_3 VGND VGND VPWR VPWR sky130_fd_sc_hd__decap_3
XFILLER_38_436 VGND VGND VPWR VPWR sky130_fd_sc_hd__decap_3
XFILLER_93_520 VGND VGND VPWR VPWR sky130_fd_sc_hd__decap_3
XFILLER_19_650 VGND VGND VPWR VPWR sky130_fd_sc_hd__decap_3
XFILLER_53_406 VGND VGND VPWR VPWR sky130_fd_sc_hd__decap_3
XFILLER_65_266 VGND VGND VPWR VPWR sky130_fd_sc_hd__fill_2
XFILLER_93_553 VGND VGND VPWR VPWR sky130_fd_sc_hd__decap_3
XFILLER_93_564 VGND VGND VPWR VPWR sky130_fd_sc_hd__decap_3
X_6980_ clkload7/A _6980_/D _6260_/Y VGND VGND VPWR VPWR _6980_/Q sky130_fd_sc_hd__dfrtp_2
XFILLER_80_214 VGND VGND VPWR VPWR sky130_fd_sc_hd__fill_1
XFILLER_93_597 VGND VGND VPWR VPWR sky130_fd_sc_hd__decap_3
XFILLER_18_182 VGND VGND VPWR VPWR sky130_fd_sc_hd__decap_3
XFILLER_34_631 VGND VGND VPWR VPWR sky130_fd_sc_hd__decap_3
XFILLER_80_236 VGND VGND VPWR VPWR sky130_fd_sc_hd__decap_3
XFILLER_21_303 VGND VGND VPWR VPWR sky130_fd_sc_hd__decap_3
XFILLER_34_675 VGND VGND VPWR VPWR sky130_fd_sc_hd__decap_3
XFILLER_61_461 VGND VGND VPWR VPWR sky130_fd_sc_hd__fill_1
X_4813_ _4813_/A _4813_/B VGND VGND VPWR VPWR _4813_/Y sky130_fd_sc_hd__nand2_2
X_4744_ _4938_/A _4744_/B VGND VGND VPWR VPWR _4744_/Y sky130_fd_sc_hd__nor2_2
XTAP_TAPCELL_ROW_103_1492 VGND VPWR sky130_fd_sc_hd__tapvpwrvgnd_1
X_4675_ _3339_/Y _3469_/B _3564_/X _3449_/A _6984_/Q VGND VGND VPWR VPWR _5067_/B
+ sky130_fd_sc_hd__o2111a_2
X_7394_ _7404_/CLK _7394_/D _6674_/Y VGND VGND VPWR VPWR _7394_/Q sky130_fd_sc_hd__dfrtp_2
X_6414_ _6637_/A VGND VGND VPWR VPWR _6414_/Y sky130_fd_sc_hd__inv_2
X_3626_ _3616_/Y _3617_/X _3625_/X VGND VGND VPWR VPWR _3733_/C sky130_fd_sc_hd__a21oi_4
XFILLER_115_441 VGND VGND VPWR VPWR sky130_fd_sc_hd__decap_3
XFILLER_115_452 VGND VGND VPWR VPWR sky130_fd_sc_hd__decap_3
X_6345_ _6672_/A VGND VGND VPWR VPWR _6345_/Y sky130_fd_sc_hd__inv_2
X_3557_ _7221_/Q _3377_/X _4279_/B1 _7125_/Q _3556_/X VGND VGND VPWR VPWR _3557_/X
+ sky130_fd_sc_hd__a221o_2
XFILLER_103_603 VGND VGND VPWR VPWR sky130_fd_sc_hd__decap_3
XFILLER_115_485 VGND VGND VPWR VPWR sky130_fd_sc_hd__decap_3
XFILLER_88_314 VGND VGND VPWR VPWR sky130_fd_sc_hd__decap_3
X_6276_ _6278_/A VGND VGND VPWR VPWR _6276_/Y sky130_fd_sc_hd__inv_2
XFILLER_102_124 VGND VGND VPWR VPWR sky130_fd_sc_hd__decap_3
XFILLER_103_647 VGND VGND VPWR VPWR sky130_fd_sc_hd__decap_3
X_5227_ _7215_/Q _5225_/B _5655_/B VGND VGND VPWR VPWR _7215_/D sky130_fd_sc_hd__a21o_2
X_3488_ _7279_/Q _3562_/A VGND VGND VPWR VPWR _3488_/X sky130_fd_sc_hd__and2_2
XFILLER_69_550 VGND VGND VPWR VPWR sky130_fd_sc_hd__fill_2
XFILLER_69_561 VGND VGND VPWR VPWR sky130_fd_sc_hd__decap_3
XFILLER_56_27 VGND VGND VPWR VPWR sky130_fd_sc_hd__fill_1
XFILLER_69_594 VGND VGND VPWR VPWR sky130_fd_sc_hd__decap_3
XFILLER_84_531 VGND VGND VPWR VPWR sky130_fd_sc_hd__fill_1
XFILLER_17_609 VGND VGND VPWR VPWR sky130_fd_sc_hd__decap_3
XFILLER_29_458 VGND VGND VPWR VPWR sky130_fd_sc_hd__decap_3
XFILLER_29_469 VGND VGND VPWR VPWR sky130_fd_sc_hd__decap_3
XFILLER_56_233 VGND VGND VPWR VPWR sky130_fd_sc_hd__decap_3
XFILLER_84_542 VGND VGND VPWR VPWR sky130_fd_sc_hd__decap_3
X_5089_ _3521_/Y _4315_/A _5086_/A _5101_/A _5088_/X VGND VGND VPWR VPWR _5089_/Y
+ sky130_fd_sc_hd__o221ai_2
X_4109_ _4376_/A _4141_/A _4141_/B _4142_/C VGND VGND VPWR VPWR _4109_/X sky130_fd_sc_hd__o31a_2
XFILLER_56_288 VGND VGND VPWR VPWR sky130_fd_sc_hd__decap_3
XFILLER_84_575 VGND VGND VPWR VPWR sky130_fd_sc_hd__decap_3
XTAP_TAPCELL_ROW_55_913 VGND VPWR sky130_fd_sc_hd__tapvpwrvgnd_1
XFILLER_112_44 VGND VGND VPWR VPWR sky130_fd_sc_hd__decap_3
XFILLER_112_77 VGND VGND VPWR VPWR sky130_fd_sc_hd__decap_3
XFILLER_25_620 VGND VGND VPWR VPWR sky130_fd_sc_hd__decap_3
XFILLER_25_653 VGND VGND VPWR VPWR sky130_fd_sc_hd__decap_3
XFILLER_37_480 VGND VGND VPWR VPWR sky130_fd_sc_hd__decap_3
XFILLER_72_15 VGND VGND VPWR VPWR sky130_fd_sc_hd__decap_3
XFILLER_40_601 VGND VGND VPWR VPWR sky130_fd_sc_hd__decap_3
XFILLER_12_336 VGND VGND VPWR VPWR sky130_fd_sc_hd__decap_3
XFILLER_24_174 VGND VGND VPWR VPWR sky130_fd_sc_hd__fill_1
XFILLER_40_634 VGND VGND VPWR VPWR sky130_fd_sc_hd__decap_3
XFILLER_40_645 VGND VGND VPWR VPWR sky130_fd_sc_hd__decap_3
XFILLER_52_483 VGND VGND VPWR VPWR sky130_fd_sc_hd__decap_3
XTAP_TAPCELL_ROW_35_670 VGND VPWR sky130_fd_sc_hd__tapvpwrvgnd_1
XFILLER_12_358 VGND VGND VPWR VPWR sky130_fd_sc_hd__decap_3
XFILLER_40_678 VGND VGND VPWR VPWR sky130_fd_sc_hd__decap_3
XFILLER_8_318 VGND VGND VPWR VPWR sky130_fd_sc_hd__decap_3
XFILLER_4_513 VGND VGND VPWR VPWR sky130_fd_sc_hd__decap_3
XFILLER_4_557 VGND VGND VPWR VPWR sky130_fd_sc_hd__decap_3
XFILLER_97_12 VGND VGND VPWR VPWR sky130_fd_sc_hd__decap_3
XFILLER_106_463 VGND VGND VPWR VPWR sky130_fd_sc_hd__decap_3
XFILLER_79_314 VGND VGND VPWR VPWR sky130_fd_sc_hd__decap_3
XTAP_TAPCELL_ROW_7_340 VGND VPWR sky130_fd_sc_hd__tapvpwrvgnd_1
XFILLER_47_222 VGND VGND VPWR VPWR sky130_fd_sc_hd__fill_2
XFILLER_87_391 VGND VGND VPWR VPWR sky130_fd_sc_hd__fill_1
XFILLER_47_233 VGND VGND VPWR VPWR sky130_fd_sc_hd__decap_3
XFILLER_75_553 VGND VGND VPWR VPWR sky130_fd_sc_hd__decap_3
XFILLER_75_564 VGND VGND VPWR VPWR sky130_fd_sc_hd__decap_3
XFILLER_47_266 VGND VGND VPWR VPWR sky130_fd_sc_hd__decap_3
XFILLER_62_203 VGND VGND VPWR VPWR sky130_fd_sc_hd__decap_3
XFILLER_75_597 VGND VGND VPWR VPWR sky130_fd_sc_hd__decap_3
XFILLER_16_631 VGND VGND VPWR VPWR sky130_fd_sc_hd__decap_3
XFILLER_47_299 VGND VGND VPWR VPWR sky130_fd_sc_hd__decap_3
XFILLER_90_545 VGND VGND VPWR VPWR sky130_fd_sc_hd__decap_3
XFILLER_16_675 VGND VGND VPWR VPWR sky130_fd_sc_hd__decap_3
XFILLER_62_258 VGND VGND VPWR VPWR sky130_fd_sc_hd__decap_3
XFILLER_90_578 VGND VGND VPWR VPWR sky130_fd_sc_hd__decap_3
XFILLER_90_589 VGND VGND VPWR VPWR sky130_fd_sc_hd__decap_3
XFILLER_31_612 VGND VGND VPWR VPWR sky130_fd_sc_hd__decap_3
XFILLER_31_623 VGND VGND VPWR VPWR sky130_fd_sc_hd__decap_3
XFILLER_30_122 VGND VGND VPWR VPWR sky130_fd_sc_hd__fill_1
XFILLER_31_656 VGND VGND VPWR VPWR sky130_fd_sc_hd__decap_3
XFILLER_30_166 VGND VGND VPWR VPWR sky130_fd_sc_hd__decap_3
XFILLER_11_380 VGND VGND VPWR VPWR sky130_fd_sc_hd__fill_2
XFILLER_7_340 VGND VGND VPWR VPWR sky130_fd_sc_hd__decap_3
XTAP_TAPCELL_ROW_96_1403 VGND VPWR sky130_fd_sc_hd__tapvpwrvgnd_1
XFILLER_116_216 VGND VGND VPWR VPWR sky130_fd_sc_hd__decap_3
X_4460_ _4460_/A _4460_/B VGND VGND VPWR VPWR _4460_/Y sky130_fd_sc_hd__nand2_2
XFILLER_116_238 VGND VGND VPWR VPWR sky130_fd_sc_hd__decap_3
X_4391_ _7401_/Q _4437_/B1 _4436_/B1 _7177_/Q _4390_/X VGND VGND VPWR VPWR _4391_/X
+ sky130_fd_sc_hd__a221o_2
XFILLER_112_400 VGND VGND VPWR VPWR sky130_fd_sc_hd__decap_3
X_3342_ _3561_/B _6982_/Q VGND VGND VPWR VPWR _5118_/D sky130_fd_sc_hd__nand2b_4
XFILLER_98_601 VGND VGND VPWR VPWR sky130_fd_sc_hd__decap_3
XFILLER_112_433 VGND VGND VPWR VPWR sky130_fd_sc_hd__decap_3
XFILLER_98_645 VGND VGND VPWR VPWR sky130_fd_sc_hd__decap_3
XFILLER_98_634 VGND VGND VPWR VPWR sky130_fd_sc_hd__decap_3
XFILLER_112_466 VGND VGND VPWR VPWR sky130_fd_sc_hd__decap_3
XFILLER_112_477 VGND VGND VPWR VPWR sky130_fd_sc_hd__decap_3
XFILLER_58_509 VGND VGND VPWR VPWR sky130_fd_sc_hd__fill_2
XFILLER_97_144 VGND VGND VPWR VPWR sky130_fd_sc_hd__decap_3
XFILLER_98_678 VGND VGND VPWR VPWR sky130_fd_sc_hd__decap_3
XFILLER_100_628 VGND VGND VPWR VPWR sky130_fd_sc_hd__decap_3
XFILLER_66_520 VGND VGND VPWR VPWR sky130_fd_sc_hd__fill_2
XFILLER_97_199 VGND VGND VPWR VPWR sky130_fd_sc_hd__decap_3
Xhold1007 _7243_/Q VGND VGND VPWR VPWR _5169_/A sky130_fd_sc_hd__dlygate4sd3_1
Xhold1018 _7259_/Q VGND VGND VPWR VPWR _5041_/A0 sky130_fd_sc_hd__dlygate4sd3_1
Xhold1029 _7183_/Q VGND VGND VPWR VPWR _5292_/A0 sky130_fd_sc_hd__dlygate4sd3_1
X_5012_ _5012_/A0 _5011_/X _5080_/S VGND VGND VPWR VPWR _7261_/D sky130_fd_sc_hd__mux2_2
XFILLER_38_244 VGND VGND VPWR VPWR sky130_fd_sc_hd__fill_1
XFILLER_66_531 VGND VGND VPWR VPWR sky130_fd_sc_hd__fill_1
XFILLER_26_417 VGND VGND VPWR VPWR sky130_fd_sc_hd__decap_3
XFILLER_38_288 VGND VGND VPWR VPWR sky130_fd_sc_hd__decap_3
XFILLER_66_575 VGND VGND VPWR VPWR sky130_fd_sc_hd__decap_3
XFILLER_19_491 VGND VGND VPWR VPWR sky130_fd_sc_hd__decap_3
XFILLER_53_225 VGND VGND VPWR VPWR sky130_fd_sc_hd__fill_1
XFILLER_53_247 VGND VGND VPWR VPWR sky130_fd_sc_hd__fill_1
XFILLER_81_545 VGND VGND VPWR VPWR sky130_fd_sc_hd__decap_3
X_6963_ _6978_/CLK _6963_/D VGND VGND VPWR VPWR _6963_/Q sky130_fd_sc_hd__dfxtp_2
XTAP_TAPCELL_ROW_105_1510 VGND VPWR sky130_fd_sc_hd__tapvpwrvgnd_1
XFILLER_22_601 VGND VGND VPWR VPWR sky130_fd_sc_hd__decap_3
XFILLER_53_258 VGND VGND VPWR VPWR sky130_fd_sc_hd__decap_3
XFILLER_81_567 VGND VGND VPWR VPWR sky130_fd_sc_hd__decap_3
X_6894_ _6943_/CLK _6894_/D VGND VGND VPWR VPWR _6894_/Q sky130_fd_sc_hd__dfxtp_2
XFILLER_22_634 VGND VGND VPWR VPWR sky130_fd_sc_hd__decap_3
XFILLER_34_472 VGND VGND VPWR VPWR sky130_fd_sc_hd__decap_3
XFILLER_34_483 VGND VGND VPWR VPWR sky130_fd_sc_hd__decap_3
XFILLER_22_645 VGND VGND VPWR VPWR sky130_fd_sc_hd__decap_3
XFILLER_22_678 VGND VGND VPWR VPWR sky130_fd_sc_hd__decap_3
XTAP_TAPCELL_ROW_32_640 VGND VPWR sky130_fd_sc_hd__tapvpwrvgnd_1
XTAP_TAPCELL_ROW_60_971 VGND VPWR sky130_fd_sc_hd__tapvpwrvgnd_1
X_4727_ _7007_/Q _4750_/B _4927_/A VGND VGND VPWR VPWR _4728_/B sky130_fd_sc_hd__o21a_2
X_4658_ _4658_/A _4658_/B VGND VGND VPWR VPWR _4658_/Y sky130_fd_sc_hd__nand2_2
Xhold830 _6749_/Q VGND VGND VPWR VPWR _6749_/D sky130_fd_sc_hd__dlygate4sd3_1
X_3609_ _5071_/A _3609_/B VGND VGND VPWR VPWR _3610_/B sky130_fd_sc_hd__nand2_2
XTAP_TAPCELL_ROW_116_1661 VGND VPWR sky130_fd_sc_hd__tapvpwrvgnd_1
XTAP_TAPCELL_ROW_116_1650 VGND VPWR sky130_fd_sc_hd__tapvpwrvgnd_1
XFILLER_1_505 VGND VGND VPWR VPWR sky130_fd_sc_hd__decap_3
XFILLER_88_100 VGND VGND VPWR VPWR sky130_fd_sc_hd__decap_3
XFILLER_89_612 VGND VGND VPWR VPWR sky130_fd_sc_hd__decap_3
XFILLER_89_623 VGND VGND VPWR VPWR sky130_fd_sc_hd__decap_3
X_7377_ _7383_/CLK _7377_/D _6657_/Y VGND VGND VPWR VPWR _7377_/Q sky130_fd_sc_hd__dfrtp_2
Xhold841 _7061_/Q VGND VGND VPWR VPWR _7061_/D sky130_fd_sc_hd__dlygate4sd3_1
Xhold852 _7118_/Q VGND VGND VPWR VPWR _7118_/D sky130_fd_sc_hd__dlygate4sd3_1
Xhold863 _7091_/Q VGND VGND VPWR VPWR _7091_/D sky130_fd_sc_hd__dlygate4sd3_1
Xmax_cap560 _4537_/C VGND VGND VPWR VPWR _4289_/A sky130_fd_sc_hd__buf_2
X_4589_ _4589_/A _4595_/B VGND VGND VPWR VPWR _7286_/D sky130_fd_sc_hd__and2_2
XFILLER_107_33 VGND VGND VPWR VPWR sky130_fd_sc_hd__decap_3
XFILLER_1_538 VGND VGND VPWR VPWR sky130_fd_sc_hd__decap_3
XFILLER_88_133 VGND VGND VPWR VPWR sky130_fd_sc_hd__decap_3
XFILLER_89_656 VGND VGND VPWR VPWR sky130_fd_sc_hd__decap_3
Xhold874 _7077_/Q VGND VGND VPWR VPWR _7077_/D sky130_fd_sc_hd__dlygate4sd3_1
Xhold885 _7095_/Q VGND VGND VPWR VPWR _7095_/D sky130_fd_sc_hd__dlygate4sd3_1
Xhold896 _7090_/Q VGND VGND VPWR VPWR _7090_/D sky130_fd_sc_hd__dlygate4sd3_1
X_6328_ _6680_/A VGND VGND VPWR VPWR _6328_/Y sky130_fd_sc_hd__inv_2
XFILLER_103_477 VGND VGND VPWR VPWR sky130_fd_sc_hd__decap_3
XFILLER_67_26 VGND VGND VPWR VPWR sky130_fd_sc_hd__decap_3
XFILLER_88_144 VGND VGND VPWR VPWR sky130_fd_sc_hd__fill_2
XFILLER_88_166 VGND VGND VPWR VPWR sky130_fd_sc_hd__fill_2
X_6259_ _6678_/A VGND VGND VPWR VPWR _6259_/Y sky130_fd_sc_hd__inv_2
XFILLER_76_317 VGND VGND VPWR VPWR sky130_fd_sc_hd__fill_1
XFILLER_17_428 VGND VGND VPWR VPWR sky130_fd_sc_hd__decap_3
XFILLER_29_255 VGND VGND VPWR VPWR sky130_fd_sc_hd__decap_3
XFILLER_57_564 VGND VGND VPWR VPWR sky130_fd_sc_hd__decap_3
XFILLER_57_597 VGND VGND VPWR VPWR sky130_fd_sc_hd__decap_3
XFILLER_29_299 VGND VGND VPWR VPWR sky130_fd_sc_hd__decap_3
XFILLER_44_225 VGND VGND VPWR VPWR sky130_fd_sc_hd__decap_3
XFILLER_72_556 VGND VGND VPWR VPWR sky130_fd_sc_hd__decap_3
XFILLER_72_589 VGND VGND VPWR VPWR sky130_fd_sc_hd__decap_3
XTAP_TAPCELL_ROW_67_1059 VGND VPWR sky130_fd_sc_hd__tapvpwrvgnd_1
XFILLER_13_612 VGND VGND VPWR VPWR sky130_fd_sc_hd__decap_3
XFILLER_13_623 VGND VGND VPWR VPWR sky130_fd_sc_hd__decap_3
XFILLER_16_74 VGND VGND VPWR VPWR sky130_fd_sc_hd__decap_3
XFILLER_16_85 VGND VGND VPWR VPWR sky130_fd_sc_hd__decap_3
XTAP_TAPCELL_ROW_80_1215 VGND VPWR sky130_fd_sc_hd__tapvpwrvgnd_1
XPHY_EDGE_ROW_11_Right_11 VGND VGND VPWR VPWR sky130_fd_sc_hd__decap_3
XFILLER_12_144 VGND VGND VPWR VPWR sky130_fd_sc_hd__decap_3
XFILLER_13_656 VGND VGND VPWR VPWR sky130_fd_sc_hd__decap_3
XFILLER_52_291 VGND VGND VPWR VPWR sky130_fd_sc_hd__decap_3
XFILLER_40_486 VGND VGND VPWR VPWR sky130_fd_sc_hd__decap_3
XFILLER_9_638 VGND VGND VPWR VPWR sky130_fd_sc_hd__decap_3
XTAP_TAPCELL_ROW_10_367 VGND VPWR sky130_fd_sc_hd__tapvpwrvgnd_1
XFILLER_4_321 VGND VGND VPWR VPWR sky130_fd_sc_hd__fill_1
XFILLER_4_343 VGND VGND VPWR VPWR sky130_fd_sc_hd__decap_3
XFILLER_113_208 VGND VGND VPWR VPWR sky130_fd_sc_hd__decap_3
XFILLER_4_365 VGND VGND VPWR VPWR sky130_fd_sc_hd__fill_1
XTAP_TAPCELL_ROW_78_1188 VGND VPWR sky130_fd_sc_hd__tapvpwrvgnd_1
XFILLER_79_100 VGND VGND VPWR VPWR sky130_fd_sc_hd__decap_3
XFILLER_79_122 VGND VGND VPWR VPWR sky130_fd_sc_hd__decap_3
XTAP_TAPCELL_ROW_91_1344 VGND VPWR sky130_fd_sc_hd__tapvpwrvgnd_1
XPHY_EDGE_ROW_20_Right_20 VGND VGND VPWR VPWR sky130_fd_sc_hd__decap_3
XFILLER_79_166 VGND VGND VPWR VPWR sky130_fd_sc_hd__fill_2
XFILLER_95_615 VGND VGND VPWR VPWR sky130_fd_sc_hd__fill_1
XFILLER_95_626 VGND VGND VPWR VPWR sky130_fd_sc_hd__decap_3
XFILLER_82_309 VGND VGND VPWR VPWR sky130_fd_sc_hd__decap_3
XFILLER_95_659 VGND VGND VPWR VPWR sky130_fd_sc_hd__decap_3
XFILLER_48_564 VGND VGND VPWR VPWR sky130_fd_sc_hd__decap_3
XFILLER_63_545 VGND VGND VPWR VPWR sky130_fd_sc_hd__decap_3
XFILLER_90_320 VGND VGND VPWR VPWR sky130_fd_sc_hd__decap_3
XFILLER_35_258 VGND VGND VPWR VPWR sky130_fd_sc_hd__fill_2
XFILLER_63_567 VGND VGND VPWR VPWR sky130_fd_sc_hd__decap_3
X_3960_ _7360_/Q _4503_/A0 _3964_/S VGND VGND VPWR VPWR _7360_/D sky130_fd_sc_hd__mux2_2
XTAP_TAPCELL_ROW_18_467 VGND VPWR sky130_fd_sc_hd__tapvpwrvgnd_1
XFILLER_16_472 VGND VGND VPWR VPWR sky130_fd_sc_hd__decap_3
XFILLER_16_494 VGND VGND VPWR VPWR sky130_fd_sc_hd__fill_1
XTAP_TAPCELL_ROW_46_798 VGND VPWR sky130_fd_sc_hd__tapvpwrvgnd_1
X_3891_ _6951_/Q _3891_/A2 _3665_/X _6957_/Q _3890_/X VGND VGND VPWR VPWR _3891_/X
+ sky130_fd_sc_hd__a221o_2
XFILLER_31_464 VGND VGND VPWR VPWR sky130_fd_sc_hd__decap_3
XFILLER_85_3 VGND VGND VPWR VPWR sky130_fd_sc_hd__fill_1
X_5630_ _5630_/A _5634_/B VGND VGND VPWR VPWR _7013_/D sky130_fd_sc_hd__and2_2
XTAP_TAPCELL_ROW_100_1451 VGND VPWR sky130_fd_sc_hd__tapvpwrvgnd_1
XFILLER_31_497 VGND VGND VPWR VPWR sky130_fd_sc_hd__fill_1
X_5561_ hold970/X _4927_/A _4695_/X VGND VGND VPWR VPWR _7054_/D sky130_fd_sc_hd__o21a_2
XFILLER_8_660 VGND VGND VPWR VPWR sky130_fd_sc_hd__decap_3
X_7300_ _7328_/CLK _7300_/D _6580_/Y VGND VGND VPWR VPWR _7300_/Q sky130_fd_sc_hd__dfrtp_2
XFILLER_7_192 VGND VGND VPWR VPWR sky130_fd_sc_hd__fill_2
X_7231_ _7328_/CLK _7231_/D _6511_/Y VGND VGND VPWR VPWR _7231_/Q sky130_fd_sc_hd__dfrtp_2
X_4443_ _4778_/A _4778_/B _4795_/A _4787_/A _4779_/A VGND VGND VPWR VPWR _4761_/B
+ sky130_fd_sc_hd__a2111o_2
X_7162_ _7322_/CLK _7162_/D _6442_/Y VGND VGND VPWR VPWR _7162_/Q sky130_fd_sc_hd__dfrtp_2
X_4374_ _4371_/Y _4224_/C _4373_/Y VGND VGND VPWR VPWR _4374_/X sky130_fd_sc_hd__o21a_2
XFILLER_112_230 VGND VGND VPWR VPWR sky130_fd_sc_hd__decap_3
XFILLER_86_604 VGND VGND VPWR VPWR sky130_fd_sc_hd__decap_3
X_7093_ _7317_/CLK _7093_/D _6373_/Y VGND VGND VPWR VPWR _7093_/Q sky130_fd_sc_hd__dfrtp_2
X_3325_ _3323_/X _3324_/X _5670_/A VGND VGND VPWR VPWR _3326_/B sky130_fd_sc_hd__a21oi_2
XFILLER_98_442 VGND VGND VPWR VPWR sky130_fd_sc_hd__fill_1
XFILLER_112_274 VGND VGND VPWR VPWR sky130_fd_sc_hd__decap_3
XFILLER_85_103 VGND VGND VPWR VPWR sky130_fd_sc_hd__decap_3
XFILLER_85_125 VGND VGND VPWR VPWR sky130_fd_sc_hd__fill_2
XFILLER_86_637 VGND VGND VPWR VPWR sky130_fd_sc_hd__decap_3
XFILLER_86_648 VGND VGND VPWR VPWR sky130_fd_sc_hd__decap_3
XTAP_TAPCELL_ROW_111_1580 VGND VPWR sky130_fd_sc_hd__tapvpwrvgnd_1
XFILLER_98_486 VGND VGND VPWR VPWR sky130_fd_sc_hd__decap_3
XFILLER_39_564 VGND VGND VPWR VPWR sky130_fd_sc_hd__decap_3
XFILLER_66_361 VGND VGND VPWR VPWR sky130_fd_sc_hd__decap_3
XFILLER_85_169 VGND VGND VPWR VPWR sky130_fd_sc_hd__decap_3
XFILLER_94_681 VGND VGND VPWR VPWR sky130_fd_sc_hd__decap_3
XFILLER_39_597 VGND VGND VPWR VPWR sky130_fd_sc_hd__decap_3
XFILLER_54_523 VGND VGND VPWR VPWR sky130_fd_sc_hd__fill_1
XFILLER_93_180 VGND VGND VPWR VPWR sky130_fd_sc_hd__fill_2
XFILLER_54_578 VGND VGND VPWR VPWR sky130_fd_sc_hd__decap_3
XFILLER_54_589 VGND VGND VPWR VPWR sky130_fd_sc_hd__decap_3
X_6946_ clkload8/A _6946_/D VGND VGND VPWR VPWR _6946_/Q sky130_fd_sc_hd__dfxtp_2
XFILLER_41_228 VGND VGND VPWR VPWR sky130_fd_sc_hd__decap_3
XFILLER_34_291 VGND VGND VPWR VPWR sky130_fd_sc_hd__decap_3
X_6877_ clkload7/A _6877_/D VGND VGND VPWR VPWR _6877_/Q sky130_fd_sc_hd__dfxtp_2
XFILLER_10_604 VGND VGND VPWR VPWR sky130_fd_sc_hd__decap_3
XFILLER_22_464 VGND VGND VPWR VPWR sky130_fd_sc_hd__decap_3
XFILLER_10_637 VGND VGND VPWR VPWR sky130_fd_sc_hd__decap_3
XFILLER_10_648 VGND VGND VPWR VPWR sky130_fd_sc_hd__decap_3
XFILLER_108_525 VGND VGND VPWR VPWR sky130_fd_sc_hd__decap_3
XFILLER_6_619 VGND VGND VPWR VPWR sky130_fd_sc_hd__decap_3
XFILLER_108_536 VGND VGND VPWR VPWR sky130_fd_sc_hd__decap_3
XFILLER_108_569 VGND VGND VPWR VPWR sky130_fd_sc_hd__decap_3
XFILLER_1_302 VGND VGND VPWR VPWR sky130_fd_sc_hd__decap_3
XFILLER_89_420 VGND VGND VPWR VPWR sky130_fd_sc_hd__decap_3
Xhold660 _6746_/Q VGND VGND VPWR VPWR _6746_/D sky130_fd_sc_hd__dlygate4sd3_1
Xhold671 _6814_/Q VGND VGND VPWR VPWR _6814_/D sky130_fd_sc_hd__dlygate4sd3_1
XFILLER_77_615 VGND VGND VPWR VPWR sky130_fd_sc_hd__fill_1
XFILLER_89_442 VGND VGND VPWR VPWR sky130_fd_sc_hd__decap_3
Xhold682 _6860_/Q VGND VGND VPWR VPWR _6860_/D sky130_fd_sc_hd__dlygate4sd3_1
Xhold693 _6910_/Q VGND VGND VPWR VPWR _6910_/D sky130_fd_sc_hd__dlygate4sd3_1
XFILLER_77_626 VGND VGND VPWR VPWR sky130_fd_sc_hd__decap_3
XFILLER_103_296 VGND VGND VPWR VPWR sky130_fd_sc_hd__decap_3
XFILLER_76_158 VGND VGND VPWR VPWR sky130_fd_sc_hd__fill_2
XFILLER_77_659 VGND VGND VPWR VPWR sky130_fd_sc_hd__decap_3
XFILLER_92_607 VGND VGND VPWR VPWR sky130_fd_sc_hd__decap_3
XFILLER_94_24 VGND VGND VPWR VPWR sky130_fd_sc_hd__decap_3
XFILLER_64_309 VGND VGND VPWR VPWR sky130_fd_sc_hd__fill_2
XFILLER_76_169 VGND VGND VPWR VPWR sky130_fd_sc_hd__decap_3
XFILLER_17_214 VGND VGND VPWR VPWR sky130_fd_sc_hd__decap_3
XFILLER_17_225 VGND VGND VPWR VPWR sky130_fd_sc_hd__decap_3
XFILLER_45_545 VGND VGND VPWR VPWR sky130_fd_sc_hd__fill_2
XFILLER_91_128 VGND VGND VPWR VPWR sky130_fd_sc_hd__decap_3
XFILLER_94_79 VGND VGND VPWR VPWR sky130_fd_sc_hd__decap_3
XFILLER_27_95 VGND VGND VPWR VPWR sky130_fd_sc_hd__decap_3
XFILLER_45_567 VGND VGND VPWR VPWR sky130_fd_sc_hd__decap_3
XFILLER_72_353 VGND VGND VPWR VPWR sky130_fd_sc_hd__decap_3
XFILLER_32_206 VGND VGND VPWR VPWR sky130_fd_sc_hd__decap_3
XTAP_TAPCELL_ROW_15_426 VGND VPWR sky130_fd_sc_hd__tapvpwrvgnd_1
XFILLER_13_420 VGND VGND VPWR VPWR sky130_fd_sc_hd__decap_3
XTAP_TAPCELL_ROW_43_768 VGND VPWR sky130_fd_sc_hd__tapvpwrvgnd_1
XTAP_TAPCELL_ROW_15_437 VGND VPWR sky130_fd_sc_hd__tapvpwrvgnd_1
XFILLER_9_435 VGND VGND VPWR VPWR sky130_fd_sc_hd__decap_3
XFILLER_9_402 VGND VGND VPWR VPWR sky130_fd_sc_hd__decap_3
XFILLER_13_497 VGND VGND VPWR VPWR sky130_fd_sc_hd__decap_3
XFILLER_5_641 VGND VGND VPWR VPWR sky130_fd_sc_hd__decap_3
XFILLER_114_528 VGND VGND VPWR VPWR sky130_fd_sc_hd__decap_3
XFILLER_107_591 VGND VGND VPWR VPWR sky130_fd_sc_hd__decap_3
XFILLER_114_539 VGND VGND VPWR VPWR sky130_fd_sc_hd__decap_3
XFILLER_4_11 VGND VGND VPWR VPWR sky130_fd_sc_hd__decap_3
XFILLER_4_173 VGND VGND VPWR VPWR sky130_fd_sc_hd__decap_3
XFILLER_5_685 VGND VGND VPWR VPWR sky130_fd_sc_hd__decap_3
XFILLER_99_228 VGND VGND VPWR VPWR sky130_fd_sc_hd__decap_3
XFILLER_4_66 VGND VGND VPWR VPWR sky130_fd_sc_hd__fill_1
XFILLER_68_604 VGND VGND VPWR VPWR sky130_fd_sc_hd__decap_3
XFILLER_68_637 VGND VGND VPWR VPWR sky130_fd_sc_hd__decap_3
XFILLER_68_648 VGND VGND VPWR VPWR sky130_fd_sc_hd__decap_3
XFILLER_95_412 VGND VGND VPWR VPWR sky130_fd_sc_hd__decap_3
XFILLER_95_445 VGND VGND VPWR VPWR sky130_fd_sc_hd__decap_3
X_4090_ _7302_/Q _4823_/S _4088_/X _4089_/X VGND VGND VPWR VPWR _4090_/X sky130_fd_sc_hd__a211o_2
XFILLER_83_629 VGND VGND VPWR VPWR sky130_fd_sc_hd__decap_3
XFILLER_76_681 VGND VGND VPWR VPWR sky130_fd_sc_hd__decap_3
XFILLER_82_128 VGND VGND VPWR VPWR sky130_fd_sc_hd__decap_3
XFILLER_36_578 VGND VGND VPWR VPWR sky130_fd_sc_hd__decap_3
XFILLER_63_353 VGND VGND VPWR VPWR sky130_fd_sc_hd__fill_2
XFILLER_91_662 VGND VGND VPWR VPWR sky130_fd_sc_hd__decap_3
XFILLER_91_673 VGND VGND VPWR VPWR sky130_fd_sc_hd__decap_3
Xplace331 _5737_/S VGND VGND VPWR VPWR _5735_/S sky130_fd_sc_hd__buf_2
Xplace320 _5292_/S VGND VGND VPWR VPWR _5286_/S sky130_fd_sc_hd__buf_2
X_6800_ _6954_/CLK _6800_/D VGND VGND VPWR VPWR _6800_/Q sky130_fd_sc_hd__dfxtp_2
XFILLER_23_206 VGND VGND VPWR VPWR sky130_fd_sc_hd__decap_3
XFILLER_36_589 VGND VGND VPWR VPWR sky130_fd_sc_hd__decap_3
XFILLER_63_386 VGND VGND VPWR VPWR sky130_fd_sc_hd__decap_3
XFILLER_90_161 VGND VGND VPWR VPWR sky130_fd_sc_hd__fill_2
XFILLER_90_183 VGND VGND VPWR VPWR sky130_fd_sc_hd__decap_3
Xplace364 _4352_/B1 VGND VGND VPWR VPWR _4267_/B1 sky130_fd_sc_hd__buf_2
Xplace353 _4351_/A2 VGND VGND VPWR VPWR _4434_/A2 sky130_fd_sc_hd__buf_2
Xplace342 _5425_/S VGND VGND VPWR VPWR _5429_/S sky130_fd_sc_hd__buf_2
X_4992_ _4987_/A _4991_/Y _4814_/A VGND VGND VPWR VPWR _4992_/Y sky130_fd_sc_hd__a21oi_2
Xplace375 _4799_/A VGND VGND VPWR VPWR _4832_/A sky130_fd_sc_hd__buf_2
Xplace386 _5225_/B VGND VGND VPWR VPWR _5209_/B sky130_fd_sc_hd__buf_2
Xplace397 _7412_/A VGND VGND VPWR VPWR _5354_/S sky130_fd_sc_hd__buf_2
X_6731_ _6959_/CLK _6731_/D VGND VGND VPWR VPWR _6731_/Q sky130_fd_sc_hd__dfxtp_2
X_3943_ _7368_/Q _4486_/A0 _3954_/S VGND VGND VPWR VPWR _7368_/D sky130_fd_sc_hd__mux2_2
X_6662_ _6662_/A VGND VGND VPWR VPWR _6662_/Y sky130_fd_sc_hd__inv_2
X_3874_ _3874_/A _3874_/B VGND VGND VPWR VPWR _3874_/X sky130_fd_sc_hd__or2_2
Xclkbuf_3_2__f_clk clkbuf_0_clk/X VGND VGND VPWR VPWR clkload1/A sky130_fd_sc_hd__clkbuf_16
X_5613_ _5613_/A _5633_/B VGND VGND VPWR VPWR _7021_/D sky130_fd_sc_hd__or2_2
X_6593_ _6603_/A VGND VGND VPWR VPWR _6593_/Y sky130_fd_sc_hd__inv_2
XFILLER_105_517 VGND VGND VPWR VPWR sky130_fd_sc_hd__decap_3
X_7214_ _7374_/CLK _7214_/D _6494_/Y VGND VGND VPWR VPWR _7214_/Q sky130_fd_sc_hd__dfrtp_2
X_4426_ _4446_/A _4426_/B VGND VGND VPWR VPWR _4813_/A sky130_fd_sc_hd__or2_2
XFILLER_113_550 VGND VGND VPWR VPWR sky130_fd_sc_hd__decap_3
X_7145_ _7405_/CLK _7145_/D _6425_/Y VGND VGND VPWR VPWR _7145_/Q sky130_fd_sc_hd__dfrtp_2
XFILLER_113_561 VGND VGND VPWR VPWR sky130_fd_sc_hd__decap_3
XFILLER_58_103 VGND VGND VPWR VPWR sky130_fd_sc_hd__fill_1
XFILLER_59_615 VGND VGND VPWR VPWR sky130_fd_sc_hd__fill_1
XFILLER_59_626 VGND VGND VPWR VPWR sky130_fd_sc_hd__decap_3
X_4357_ _4352_/X _4356_/X _4327_/A VGND VGND VPWR VPWR _4367_/C sky130_fd_sc_hd__o21ai_2
XFILLER_100_211 VGND VGND VPWR VPWR sky130_fd_sc_hd__decap_3
XFILLER_113_594 VGND VGND VPWR VPWR sky130_fd_sc_hd__decap_3
XFILLER_59_659 VGND VGND VPWR VPWR sky130_fd_sc_hd__decap_3
XFILLER_74_607 VGND VGND VPWR VPWR sky130_fd_sc_hd__decap_3
XFILLER_86_456 VGND VGND VPWR VPWR sky130_fd_sc_hd__decap_3
X_7076_ _7362_/CLK _7076_/D _6356_/Y VGND VGND VPWR VPWR _7076_/Q sky130_fd_sc_hd__dfrtp_2
X_4288_ _4394_/A _4337_/B _4288_/C _4288_/D VGND VGND VPWR VPWR _4288_/X sky130_fd_sc_hd__or4_4
X_3308_ _6981_/Q _3331_/B VGND VGND VPWR VPWR _5118_/C sky130_fd_sc_hd__nand2_2
XFILLER_104_12 VGND VGND VPWR VPWR sky130_fd_sc_hd__decap_3
XFILLER_46_309 VGND VGND VPWR VPWR sky130_fd_sc_hd__decap_3
XFILLER_73_106 VGND VGND VPWR VPWR sky130_fd_sc_hd__decap_3
XFILLER_100_299 VGND VGND VPWR VPWR sky130_fd_sc_hd__decap_3
XFILLER_27_556 VGND VGND VPWR VPWR sky130_fd_sc_hd__decap_3
XFILLER_27_567 VGND VGND VPWR VPWR sky130_fd_sc_hd__decap_3
XFILLER_42_504 VGND VGND VPWR VPWR sky130_fd_sc_hd__decap_3
XFILLER_54_342 VGND VGND VPWR VPWR sky130_fd_sc_hd__decap_3
XFILLER_64_38 VGND VGND VPWR VPWR sky130_fd_sc_hd__decap_3
XFILLER_82_640 VGND VGND VPWR VPWR sky130_fd_sc_hd__decap_3
XFILLER_82_651 VGND VGND VPWR VPWR sky130_fd_sc_hd__decap_3
XFILLER_14_206 VGND VGND VPWR VPWR sky130_fd_sc_hd__decap_3
XFILLER_42_526 VGND VGND VPWR VPWR sky130_fd_sc_hd__decap_3
XFILLER_54_386 VGND VGND VPWR VPWR sky130_fd_sc_hd__decap_3
XFILLER_81_172 VGND VGND VPWR VPWR sky130_fd_sc_hd__decap_3
XFILLER_82_684 VGND VGND VPWR VPWR sky130_fd_sc_hd__decap_3
XTAP_TAPCELL_ROW_64_1018 VGND VPWR sky130_fd_sc_hd__tapvpwrvgnd_1
XFILLER_42_548 VGND VGND VPWR VPWR sky130_fd_sc_hd__decap_3
Xfanout21 _6678_/A VGND VGND VPWR VPWR _6672_/A sky130_fd_sc_hd__buf_2
X_6929_ _6954_/CLK _6929_/D VGND VGND VPWR VPWR _6929_/Q sky130_fd_sc_hd__dfxtp_2
XFILLER_10_401 VGND VGND VPWR VPWR sky130_fd_sc_hd__fill_1
XFILLER_22_250 VGND VGND VPWR VPWR sky130_fd_sc_hd__fill_2
XFILLER_22_261 VGND VGND VPWR VPWR sky130_fd_sc_hd__decap_3
Xfanout32 fanout33/X VGND VGND VPWR VPWR _6566_/A sky130_fd_sc_hd__buf_2
Xfanout43 fanout46/X VGND VGND VPWR VPWR _6644_/A sky130_fd_sc_hd__clkdlybuf4s25_1
Xfanout54 _6645_/A VGND VGND VPWR VPWR _6643_/A sky130_fd_sc_hd__buf_2
Xfanout65 _6651_/A VGND VGND VPWR VPWR _6649_/A sky130_fd_sc_hd__buf_2
XTAP_TAPCELL_ROW_40_727 VGND VPWR sky130_fd_sc_hd__tapvpwrvgnd_1
XFILLER_50_581 VGND VGND VPWR VPWR sky130_fd_sc_hd__decap_3
XFILLER_50_592 VGND VGND VPWR VPWR sky130_fd_sc_hd__decap_3
XFILLER_6_416 VGND VGND VPWR VPWR sky130_fd_sc_hd__decap_3
XFILLER_108_322 VGND VGND VPWR VPWR sky130_fd_sc_hd__decap_3
XFILLER_6_449 VGND VGND VPWR VPWR sky130_fd_sc_hd__decap_3
XFILLER_89_57 VGND VGND VPWR VPWR sky130_fd_sc_hd__fill_1
XTAP_TAPCELL_ROW_20_495 VGND VPWR sky130_fd_sc_hd__tapvpwrvgnd_1
XFILLER_2_622 VGND VGND VPWR VPWR sky130_fd_sc_hd__decap_3
XTAP_TAPCELL_ROW_75_1147 VGND VPWR sky130_fd_sc_hd__tapvpwrvgnd_1
XFILLER_2_666 VGND VGND VPWR VPWR sky130_fd_sc_hd__decap_3
XFILLER_104_572 VGND VGND VPWR VPWR sky130_fd_sc_hd__decap_3
XFILLER_1_165 VGND VGND VPWR VPWR sky130_fd_sc_hd__decap_3
XFILLER_77_401 VGND VGND VPWR VPWR sky130_fd_sc_hd__decap_3
XFILLER_1_198 VGND VGND VPWR VPWR sky130_fd_sc_hd__decap_3
XFILLER_64_106 VGND VGND VPWR VPWR sky130_fd_sc_hd__decap_3
XFILLER_65_629 VGND VGND VPWR VPWR sky130_fd_sc_hd__decap_3
XFILLER_77_489 VGND VGND VPWR VPWR sky130_fd_sc_hd__decap_3
XFILLER_92_415 VGND VGND VPWR VPWR sky130_fd_sc_hd__decap_3
XTAP_TAPCELL_ROW_48_827 VGND VPWR sky130_fd_sc_hd__tapvpwrvgnd_1
XFILLER_58_681 VGND VGND VPWR VPWR sky130_fd_sc_hd__decap_3
XFILLER_64_128 VGND VGND VPWR VPWR sky130_fd_sc_hd__decap_3
XFILLER_18_545 VGND VGND VPWR VPWR sky130_fd_sc_hd__decap_3
XFILLER_18_578 VGND VGND VPWR VPWR sky130_fd_sc_hd__decap_3
XFILLER_73_662 VGND VGND VPWR VPWR sky130_fd_sc_hd__decap_3
Xhold1190 _7248_/Q VGND VGND VPWR VPWR _5157_/A0 sky130_fd_sc_hd__dlygate4sd3_1
XFILLER_18_589 VGND VGND VPWR VPWR sky130_fd_sc_hd__decap_3
XFILLER_45_375 VGND VGND VPWR VPWR sky130_fd_sc_hd__fill_1
XFILLER_60_312 VGND VGND VPWR VPWR sky130_fd_sc_hd__decap_3
XFILLER_72_150 VGND VGND VPWR VPWR sky130_fd_sc_hd__decap_3
XFILLER_72_172 VGND VGND VPWR VPWR sky130_fd_sc_hd__decap_3
XFILLER_73_673 VGND VGND VPWR VPWR sky130_fd_sc_hd__decap_3
XTAP_TAPCELL_ROW_86_1287 VGND VPWR sky130_fd_sc_hd__tapvpwrvgnd_1
XTAP_TAPCELL_ROW_28_584 VGND VPWR sky130_fd_sc_hd__tapvpwrvgnd_1
XFILLER_33_559 VGND VGND VPWR VPWR sky130_fd_sc_hd__fill_1
XFILLER_54_82 VGND VGND VPWR VPWR sky130_fd_sc_hd__fill_2
XFILLER_60_345 VGND VGND VPWR VPWR sky130_fd_sc_hd__decap_3
XFILLER_72_183 VGND VGND VPWR VPWR sky130_fd_sc_hd__decap_3
XFILLER_13_261 VGND VGND VPWR VPWR sky130_fd_sc_hd__fill_2
XFILLER_41_570 VGND VGND VPWR VPWR sky130_fd_sc_hd__decap_3
XFILLER_9_221 VGND VGND VPWR VPWR sky130_fd_sc_hd__decap_3
XFILLER_9_210 VGND VGND VPWR VPWR sky130_fd_sc_hd__decap_3
XFILLER_9_254 VGND VGND VPWR VPWR sky130_fd_sc_hd__decap_3
Xclkload13 _7317_/CLK VGND VGND VPWR VPWR clkload13/Y sky130_fd_sc_hd__clkinv_2
Xclkload24 _7405_/CLK VGND VGND VPWR VPWR clkload24/X sky130_fd_sc_hd__clkbuf_8
Xclkload35 _7332_/CLK VGND VGND VPWR VPWR clkload35/X sky130_fd_sc_hd__clkbuf_8
X_3590_ _3590_/A _3590_/B _3590_/C VGND VGND VPWR VPWR _3620_/C sky130_fd_sc_hd__and3_2
X_5260_ _5260_/A0 _4964_/X _5286_/S VGND VGND VPWR VPWR _7200_/D sky130_fd_sc_hd__mux2_2
XFILLER_48_3 VGND VGND VPWR VPWR sky130_fd_sc_hd__decap_3
XFILLER_5_493 VGND VGND VPWR VPWR sky130_fd_sc_hd__decap_3
X_4211_ _4633_/A _4143_/X _4206_/X _4384_/A _4210_/X VGND VGND VPWR VPWR _4778_/A
+ sky130_fd_sc_hd__a221oi_2
XFILLER_68_412 VGND VGND VPWR VPWR sky130_fd_sc_hd__decap_3
XFILLER_110_531 VGND VGND VPWR VPWR sky130_fd_sc_hd__fill_1
XFILLER_110_542 VGND VGND VPWR VPWR sky130_fd_sc_hd__decap_3
X_4142_ _4205_/A _4142_/B _4142_/C VGND VGND VPWR VPWR _4142_/X sky130_fd_sc_hd__and3_2
XFILLER_110_575 VGND VGND VPWR VPWR sky130_fd_sc_hd__decap_3
XFILLER_28_309 VGND VGND VPWR VPWR sky130_fd_sc_hd__decap_3
XFILLER_56_607 VGND VGND VPWR VPWR sky130_fd_sc_hd__decap_3
XFILLER_83_415 VGND VGND VPWR VPWR sky130_fd_sc_hd__decap_3
XFILLER_95_253 VGND VGND VPWR VPWR sky130_fd_sc_hd__decap_3
X_4073_ _7275_/Q _4437_/A2 _4070_/X _4072_/X VGND VGND VPWR VPWR _4073_/X sky130_fd_sc_hd__a211o_2
XFILLER_48_180 VGND VGND VPWR VPWR sky130_fd_sc_hd__decap_3
XFILLER_83_437 VGND VGND VPWR VPWR sky130_fd_sc_hd__fill_2
XFILLER_95_286 VGND VGND VPWR VPWR sky130_fd_sc_hd__decap_3
XFILLER_64_640 VGND VGND VPWR VPWR sky130_fd_sc_hd__decap_3
XFILLER_64_651 VGND VGND VPWR VPWR sky130_fd_sc_hd__decap_3
XFILLER_24_515 VGND VGND VPWR VPWR sky130_fd_sc_hd__decap_3
XFILLER_51_301 VGND VGND VPWR VPWR sky130_fd_sc_hd__decap_3
XFILLER_64_684 VGND VGND VPWR VPWR sky130_fd_sc_hd__decap_3
XFILLER_24_548 VGND VGND VPWR VPWR sky130_fd_sc_hd__decap_3
XFILLER_51_334 VGND VGND VPWR VPWR sky130_fd_sc_hd__fill_2
X_4975_ _5593_/B _4975_/B VGND VGND VPWR VPWR _4975_/Y sky130_fd_sc_hd__nand2_2
X_6714_ _6941_/CLK _6714_/D VGND VGND VPWR VPWR _6714_/Q sky130_fd_sc_hd__dfxtp_2
X_3926_ _6913_/Q _3926_/A2 _3926_/B1 _6777_/Q _3925_/X VGND VGND VPWR VPWR _3926_/X
+ sky130_fd_sc_hd__a221o_2
XFILLER_32_570 VGND VGND VPWR VPWR sky130_fd_sc_hd__decap_3
XFILLER_32_592 VGND VGND VPWR VPWR sky130_fd_sc_hd__decap_3
XFILLER_50_29 VGND VGND VPWR VPWR sky130_fd_sc_hd__decap_3
Xclkload7 clkload7/A VGND VGND VPWR VPWR clkload7/Y sky130_fd_sc_hd__clkinv_2
X_6645_ _6645_/A VGND VGND VPWR VPWR _6645_/Y sky130_fd_sc_hd__inv_2
X_3857_ _3857_/A1 _5104_/A _3856_/X VGND VGND VPWR VPWR _7387_/D sky130_fd_sc_hd__a21o_2
X_6576_ _6608_/A VGND VGND VPWR VPWR _6576_/Y sky130_fd_sc_hd__inv_2
X_3788_ _3741_/X _3785_/X _3787_/X _3735_/X VGND VGND VPWR VPWR _3788_/X sky130_fd_sc_hd__a22o_2
XFILLER_105_325 VGND VGND VPWR VPWR sky130_fd_sc_hd__decap_3
XFILLER_1_9 VGND VGND VPWR VPWR sky130_fd_sc_hd__decap_3
XFILLER_78_209 VGND VGND VPWR VPWR sky130_fd_sc_hd__decap_3
Xoutput540 _3403_/A VGND VGND VPWR VPWR pc_out[2] sky130_fd_sc_hd__clkdlybuf4s25_1
XFILLER_59_412 VGND VGND VPWR VPWR sky130_fd_sc_hd__decap_3
X_4409_ _4425_/A _4409_/B VGND VGND VPWR VPWR _4411_/B sky130_fd_sc_hd__nand2_2
XFILLER_99_570 VGND VGND VPWR VPWR sky130_fd_sc_hd__decap_3
XFILLER_101_520 VGND VGND VPWR VPWR sky130_fd_sc_hd__decap_3
XFILLER_115_33 VGND VGND VPWR VPWR sky130_fd_sc_hd__decap_3
X_7128_ _7353_/CLK _7128_/D _6408_/Y VGND VGND VPWR VPWR _7128_/Q sky130_fd_sc_hd__dfrtp_2
XFILLER_101_553 VGND VGND VPWR VPWR sky130_fd_sc_hd__decap_3
XFILLER_101_564 VGND VGND VPWR VPWR sky130_fd_sc_hd__decap_3
XFILLER_115_66 VGND VGND VPWR VPWR sky130_fd_sc_hd__decap_3
XFILLER_47_629 VGND VGND VPWR VPWR sky130_fd_sc_hd__decap_3
XFILLER_59_478 VGND VGND VPWR VPWR sky130_fd_sc_hd__decap_3
XFILLER_86_242 VGND VGND VPWR VPWR sky130_fd_sc_hd__decap_3
XFILLER_86_253 VGND VGND VPWR VPWR sky130_fd_sc_hd__fill_1
X_7059_ _7311_/CLK _7059_/D _6339_/Y VGND VGND VPWR VPWR _7059_/Q sky130_fd_sc_hd__dfrtp_2
XTAP_TAPCELL_ROW_70_1088 VGND VPWR sky130_fd_sc_hd__tapvpwrvgnd_1
XFILLER_101_597 VGND VGND VPWR VPWR sky130_fd_sc_hd__decap_3
XFILLER_115_99 VGND VGND VPWR VPWR sky130_fd_sc_hd__decap_3
XFILLER_27_320 VGND VGND VPWR VPWR sky130_fd_sc_hd__decap_3
XFILLER_86_286 VGND VGND VPWR VPWR sky130_fd_sc_hd__fill_2
XFILLER_86_297 VGND VGND VPWR VPWR sky130_fd_sc_hd__decap_3
XFILLER_55_662 VGND VGND VPWR VPWR sky130_fd_sc_hd__decap_3
XFILLER_15_526 VGND VGND VPWR VPWR sky130_fd_sc_hd__decap_3
XFILLER_54_161 VGND VGND VPWR VPWR sky130_fd_sc_hd__decap_3
XFILLER_55_673 VGND VGND VPWR VPWR sky130_fd_sc_hd__decap_3
XFILLER_61_109 VGND VGND VPWR VPWR sky130_fd_sc_hd__decap_3
XFILLER_70_610 VGND VGND VPWR VPWR sky130_fd_sc_hd__decap_3
XFILLER_15_559 VGND VGND VPWR VPWR sky130_fd_sc_hd__fill_1
XFILLER_42_334 VGND VGND VPWR VPWR sky130_fd_sc_hd__decap_3
XFILLER_54_194 VGND VGND VPWR VPWR sky130_fd_sc_hd__fill_2
XFILLER_70_643 VGND VGND VPWR VPWR sky130_fd_sc_hd__fill_1
XFILLER_70_654 VGND VGND VPWR VPWR sky130_fd_sc_hd__decap_3
XFILLER_70_687 VGND VGND VPWR VPWR sky130_fd_sc_hd__decap_3
XTAP_TAPCELL_ROW_53_885 VGND VPWR sky130_fd_sc_hd__tapvpwrvgnd_1
XTAP_TAPCELL_ROW_25_554 VGND VPWR sky130_fd_sc_hd__tapvpwrvgnd_1
XFILLER_23_570 VGND VGND VPWR VPWR sky130_fd_sc_hd__decap_3
XFILLER_24_74 VGND VGND VPWR VPWR sky130_fd_sc_hd__fill_1
XFILLER_24_85 VGND VGND VPWR VPWR sky130_fd_sc_hd__fill_2
XFILLER_10_253 VGND VGND VPWR VPWR sky130_fd_sc_hd__decap_3
XFILLER_109_620 VGND VGND VPWR VPWR sky130_fd_sc_hd__decap_3
XFILLER_108_141 VGND VGND VPWR VPWR sky130_fd_sc_hd__fill_2
XFILLER_108_152 VGND VGND VPWR VPWR sky130_fd_sc_hd__fill_1
XFILLER_109_653 VGND VGND VPWR VPWR sky130_fd_sc_hd__decap_3
XFILLER_40_40 VGND VGND VPWR VPWR sky130_fd_sc_hd__fill_2
XFILLER_2_452 VGND VGND VPWR VPWR sky130_fd_sc_hd__decap_3
XFILLER_97_529 VGND VGND VPWR VPWR sky130_fd_sc_hd__decap_3
XFILLER_1_12 VGND VGND VPWR VPWR sky130_fd_sc_hd__decap_3
XFILLER_37_106 VGND VGND VPWR VPWR sky130_fd_sc_hd__decap_3
XFILLER_38_607 VGND VGND VPWR VPWR sky130_fd_sc_hd__decap_3
XFILLER_77_253 VGND VGND VPWR VPWR sky130_fd_sc_hd__decap_3
XTAP_TAPCELL_ROW_88_1305 VGND VPWR sky130_fd_sc_hd__tapvpwrvgnd_1
XFILLER_92_212 VGND VGND VPWR VPWR sky130_fd_sc_hd__decap_3
XFILLER_46_640 VGND VGND VPWR VPWR sky130_fd_sc_hd__decap_3
XFILLER_46_651 VGND VGND VPWR VPWR sky130_fd_sc_hd__decap_3
XFILLER_92_256 VGND VGND VPWR VPWR sky130_fd_sc_hd__decap_3
XFILLER_46_684 VGND VGND VPWR VPWR sky130_fd_sc_hd__decap_3
XFILLER_80_429 VGND VGND VPWR VPWR sky130_fd_sc_hd__decap_3
XFILLER_33_345 VGND VGND VPWR VPWR sky130_fd_sc_hd__decap_3
XFILLER_61_632 VGND VGND VPWR VPWR sky130_fd_sc_hd__decap_3
XFILLER_61_665 VGND VGND VPWR VPWR sky130_fd_sc_hd__decap_3
XFILLER_61_676 VGND VGND VPWR VPWR sky130_fd_sc_hd__decap_3
XFILLER_14_581 VGND VGND VPWR VPWR sky130_fd_sc_hd__decap_3
XFILLER_14_592 VGND VGND VPWR VPWR sky130_fd_sc_hd__decap_3
XFILLER_60_197 VGND VGND VPWR VPWR sky130_fd_sc_hd__decap_3
X_4760_ _4927_/A _4760_/B VGND VGND VPWR VPWR _4760_/Y sky130_fd_sc_hd__nand2_2
X_4691_ _7004_/Q _4665_/X _4804_/A _4757_/A VGND VGND VPWR VPWR _4749_/B sky130_fd_sc_hd__a31o_2
X_3711_ _3746_/A VGND VGND VPWR VPWR _3735_/A sky130_fd_sc_hd__inv_2
XTAP_TAPCELL_ROW_99_1445 VGND VPWR sky130_fd_sc_hd__tapvpwrvgnd_1
XTAP_TAPCELL_ROW_99_1434 VGND VPWR sky130_fd_sc_hd__tapvpwrvgnd_1
XPHY_EDGE_ROW_112_Right_112 VGND VGND VPWR VPWR sky130_fd_sc_hd__decap_3
X_6430_ _6558_/A VGND VGND VPWR VPWR _6430_/Y sky130_fd_sc_hd__inv_2
X_3642_ _6718_/Q _6808_/Q _6896_/Q _6944_/Q _3991_/B _3665_/B VGND VGND VPWR VPWR
+ _3642_/X sky130_fd_sc_hd__mux4_2
X_6361_ _6364_/A VGND VGND VPWR VPWR _6361_/Y sky130_fd_sc_hd__inv_2
XFILLER_114_100 VGND VGND VPWR VPWR sky130_fd_sc_hd__decap_3
XFILLER_115_612 VGND VGND VPWR VPWR sky130_fd_sc_hd__decap_3
XFILLER_115_623 VGND VGND VPWR VPWR sky130_fd_sc_hd__decap_3
X_5312_ _5312_/A0 _4864_/X _5323_/S VGND VGND VPWR VPWR _7174_/D sky130_fd_sc_hd__mux2_2
X_3573_ _7316_/Q _3987_/S _4528_/B _7284_/Q VGND VGND VPWR VPWR _3573_/X sky130_fd_sc_hd__a22o_2
XPHY_EDGE_ROW_49_Right_49 VGND VGND VPWR VPWR sky130_fd_sc_hd__decap_3
XFILLER_114_144 VGND VGND VPWR VPWR sky130_fd_sc_hd__decap_3
XFILLER_115_656 VGND VGND VPWR VPWR sky130_fd_sc_hd__decap_3
X_6292_ _6608_/A VGND VGND VPWR VPWR _6292_/Y sky130_fd_sc_hd__inv_2
X_5243_ _5243_/A0 _4822_/X _5262_/S VGND VGND VPWR VPWR _7208_/D sky130_fd_sc_hd__mux2_2
XFILLER_29_629 VGND VGND VPWR VPWR sky130_fd_sc_hd__decap_3
XFILLER_56_404 VGND VGND VPWR VPWR sky130_fd_sc_hd__decap_3
XFILLER_68_253 VGND VGND VPWR VPWR sky130_fd_sc_hd__fill_2
XFILLER_96_551 VGND VGND VPWR VPWR sky130_fd_sc_hd__decap_3
X_4125_ _4205_/A _4117_/B _4117_/C _4124_/B VGND VGND VPWR VPWR _4125_/X sky130_fd_sc_hd__a31o_2
XFILLER_110_394 VGND VGND VPWR VPWR sky130_fd_sc_hd__decap_3
XFILLER_68_275 VGND VGND VPWR VPWR sky130_fd_sc_hd__fill_2
XFILLER_83_223 VGND VGND VPWR VPWR sky130_fd_sc_hd__fill_1
XFILLER_96_584 VGND VGND VPWR VPWR sky130_fd_sc_hd__decap_3
XFILLER_96_595 VGND VGND VPWR VPWR sky130_fd_sc_hd__decap_3
XFILLER_56_459 VGND VGND VPWR VPWR sky130_fd_sc_hd__decap_3
X_4056_ _7340_/Q _4390_/B1 _4428_/B1 _7148_/Q VGND VGND VPWR VPWR _4056_/X sky130_fd_sc_hd__a22o_2
XPHY_EDGE_ROW_58_Right_58 VGND VGND VPWR VPWR sky130_fd_sc_hd__decap_3
XFILLER_24_301 VGND VGND VPWR VPWR sky130_fd_sc_hd__decap_3
XFILLER_37_662 VGND VGND VPWR VPWR sky130_fd_sc_hd__decap_3
XFILLER_37_673 VGND VGND VPWR VPWR sky130_fd_sc_hd__decap_3
XFILLER_52_610 VGND VGND VPWR VPWR sky130_fd_sc_hd__decap_3
XFILLER_64_470 VGND VGND VPWR VPWR sky130_fd_sc_hd__decap_3
XFILLER_71_429 VGND VGND VPWR VPWR sky130_fd_sc_hd__fill_1
XTAP_TAPCELL_ROW_108_1552 VGND VPWR sky130_fd_sc_hd__tapvpwrvgnd_1
XFILLER_24_323 VGND VGND VPWR VPWR sky130_fd_sc_hd__decap_3
XFILLER_36_194 VGND VGND VPWR VPWR sky130_fd_sc_hd__fill_2
XFILLER_52_643 VGND VGND VPWR VPWR sky130_fd_sc_hd__fill_1
XFILLER_52_654 VGND VGND VPWR VPWR sky130_fd_sc_hd__decap_3
XFILLER_24_356 VGND VGND VPWR VPWR sky130_fd_sc_hd__decap_3
XFILLER_52_687 VGND VGND VPWR VPWR sky130_fd_sc_hd__decap_3
XFILLER_12_529 VGND VGND VPWR VPWR sky130_fd_sc_hd__decap_3
X_4958_ _4983_/B VGND VGND VPWR VPWR _4958_/Y sky130_fd_sc_hd__inv_2
XTAP_TAPCELL_ROW_22_513 VGND VPWR sky130_fd_sc_hd__tapvpwrvgnd_1
XFILLER_20_551 VGND VGND VPWR VPWR sky130_fd_sc_hd__decap_3
X_4889_ _4890_/B _4889_/B VGND VGND VPWR VPWR _4889_/Y sky130_fd_sc_hd__xnor2_2
X_3909_ _3909_/A1 _5104_/A _3908_/X VGND VGND VPWR VPWR _7379_/D sky130_fd_sc_hd__a21o_2
XTAP_TAPCELL_ROW_50_855 VGND VPWR sky130_fd_sc_hd__tapvpwrvgnd_1
XFILLER_20_584 VGND VGND VPWR VPWR sky130_fd_sc_hd__decap_3
X_6628_ _6628_/A VGND VGND VPWR VPWR _6628_/Y sky130_fd_sc_hd__inv_2
XFILLER_106_601 VGND VGND VPWR VPWR sky130_fd_sc_hd__decap_3
XFILLER_20_595 VGND VGND VPWR VPWR sky130_fd_sc_hd__decap_3
XPHY_EDGE_ROW_67_Right_67 VGND VGND VPWR VPWR sky130_fd_sc_hd__decap_3
XFILLER_106_634 VGND VGND VPWR VPWR sky130_fd_sc_hd__decap_3
X_6559_ _6624_/A VGND VGND VPWR VPWR _6559_/Y sky130_fd_sc_hd__inv_2
XFILLER_105_122 VGND VGND VPWR VPWR sky130_fd_sc_hd__decap_3
XFILLER_106_645 VGND VGND VPWR VPWR sky130_fd_sc_hd__decap_3
XFILLER_10_32 VGND VGND VPWR VPWR sky130_fd_sc_hd__fill_1
XFILLER_106_678 VGND VGND VPWR VPWR sky130_fd_sc_hd__decap_3
XTAP_TAPCELL_ROW_72_1117 VGND VPWR sky130_fd_sc_hd__tapvpwrvgnd_1
XFILLER_59_231 VGND VGND VPWR VPWR sky130_fd_sc_hd__decap_3
XFILLER_87_540 VGND VGND VPWR VPWR sky130_fd_sc_hd__decap_3
XFILLER_19_30 VGND VGND VPWR VPWR sky130_fd_sc_hd__fill_2
XFILLER_87_573 VGND VGND VPWR VPWR sky130_fd_sc_hd__decap_3
XFILLER_101_361 VGND VGND VPWR VPWR sky130_fd_sc_hd__fill_1
XFILLER_101_383 VGND VGND VPWR VPWR sky130_fd_sc_hd__decap_3
XFILLER_19_41 VGND VGND VPWR VPWR sky130_fd_sc_hd__decap_3
XFILLER_47_426 VGND VGND VPWR VPWR sky130_fd_sc_hd__fill_1
XFILLER_74_212 VGND VGND VPWR VPWR sky130_fd_sc_hd__decap_3
XPHY_EDGE_ROW_76_Right_76 VGND VGND VPWR VPWR sky130_fd_sc_hd__decap_3
XFILLER_28_640 VGND VGND VPWR VPWR sky130_fd_sc_hd__decap_3
XFILLER_28_651 VGND VGND VPWR VPWR sky130_fd_sc_hd__decap_3
XFILLER_74_256 VGND VGND VPWR VPWR sky130_fd_sc_hd__decap_3
XTAP_TAPCELL_ROW_58_944 VGND VPWR sky130_fd_sc_hd__tapvpwrvgnd_1
XFILLER_28_684 VGND VGND VPWR VPWR sky130_fd_sc_hd__decap_3
XFILLER_74_289 VGND VGND VPWR VPWR sky130_fd_sc_hd__fill_1
XTAP_TAPCELL_ROW_2_271 VGND VPWR sky130_fd_sc_hd__tapvpwrvgnd_1
XFILLER_43_632 VGND VGND VPWR VPWR sky130_fd_sc_hd__decap_3
XFILLER_43_665 VGND VGND VPWR VPWR sky130_fd_sc_hd__decap_3
XFILLER_43_676 VGND VGND VPWR VPWR sky130_fd_sc_hd__decap_3
XTAP_TAPCELL_ROW_83_1246 VGND VPWR sky130_fd_sc_hd__tapvpwrvgnd_1
XFILLER_30_326 VGND VGND VPWR VPWR sky130_fd_sc_hd__fill_2
XFILLER_11_573 VGND VGND VPWR VPWR sky130_fd_sc_hd__decap_3
XFILLER_7_511 VGND VGND VPWR VPWR sky130_fd_sc_hd__decap_3
XPHY_EDGE_ROW_85_Right_85 VGND VGND VPWR VPWR sky130_fd_sc_hd__decap_3
XFILLER_7_544 VGND VGND VPWR VPWR sky130_fd_sc_hd__decap_3
XFILLER_109_461 VGND VGND VPWR VPWR sky130_fd_sc_hd__decap_3
XFILLER_7_588 VGND VGND VPWR VPWR sky130_fd_sc_hd__decap_3
XFILLER_109_494 VGND VGND VPWR VPWR sky130_fd_sc_hd__decap_3
XTAP_TAPCELL_ROW_94_1375 VGND VPWR sky130_fd_sc_hd__tapvpwrvgnd_1
XFILLER_112_604 VGND VGND VPWR VPWR sky130_fd_sc_hd__decap_3
XFILLER_111_125 VGND VGND VPWR VPWR sky130_fd_sc_hd__decap_3
XFILLER_112_637 VGND VGND VPWR VPWR sky130_fd_sc_hd__decap_3
XFILLER_112_648 VGND VGND VPWR VPWR sky130_fd_sc_hd__decap_3
XFILLER_32_6 VGND VGND VPWR VPWR sky130_fd_sc_hd__fill_2
XFILLER_97_337 VGND VGND VPWR VPWR sky130_fd_sc_hd__decap_3
XPHY_EDGE_ROW_29_Left_146 VGND VGND VPWR VPWR sky130_fd_sc_hd__decap_3
XFILLER_111_169 VGND VGND VPWR VPWR sky130_fd_sc_hd__decap_3
XFILLER_78_551 VGND VGND VPWR VPWR sky130_fd_sc_hd__decap_3
XPHY_EDGE_ROW_94_Right_94 VGND VGND VPWR VPWR sky130_fd_sc_hd__decap_3
XFILLER_65_212 VGND VGND VPWR VPWR sky130_fd_sc_hd__decap_3
XFILLER_78_584 VGND VGND VPWR VPWR sky130_fd_sc_hd__decap_3
XFILLER_78_595 VGND VGND VPWR VPWR sky130_fd_sc_hd__decap_3
XFILLER_93_532 VGND VGND VPWR VPWR sky130_fd_sc_hd__decap_3
XFILLER_38_448 VGND VGND VPWR VPWR sky130_fd_sc_hd__decap_3
XFILLER_65_234 VGND VGND VPWR VPWR sky130_fd_sc_hd__decap_3
XFILLER_19_662 VGND VGND VPWR VPWR sky130_fd_sc_hd__decap_3
XFILLER_19_673 VGND VGND VPWR VPWR sky130_fd_sc_hd__decap_3
XFILLER_34_610 VGND VGND VPWR VPWR sky130_fd_sc_hd__decap_3
XFILLER_93_576 VGND VGND VPWR VPWR sky130_fd_sc_hd__decap_3
XFILLER_34_643 VGND VGND VPWR VPWR sky130_fd_sc_hd__fill_1
XFILLER_80_248 VGND VGND VPWR VPWR sky130_fd_sc_hd__decap_3
XFILLER_34_654 VGND VGND VPWR VPWR sky130_fd_sc_hd__decap_3
XFILLER_34_687 VGND VGND VPWR VPWR sky130_fd_sc_hd__decap_3
XFILLER_21_337 VGND VGND VPWR VPWR sky130_fd_sc_hd__decap_3
X_4812_ _4827_/A _4827_/B VGND VGND VPWR VPWR _4812_/Y sky130_fd_sc_hd__nor2_2
XPHY_EDGE_ROW_38_Left_155 VGND VGND VPWR VPWR sky130_fd_sc_hd__decap_3
X_4743_ _4745_/A _4081_/X _4741_/X _4742_/Y VGND VGND VPWR VPWR _4743_/X sky130_fd_sc_hd__a31o_2
XTAP_TAPCELL_ROW_103_1493 VGND VPWR sky130_fd_sc_hd__tapvpwrvgnd_1
XTAP_TAPCELL_ROW_103_1482 VGND VPWR sky130_fd_sc_hd__tapvpwrvgnd_1
X_6413_ _6638_/A VGND VGND VPWR VPWR _6413_/Y sky130_fd_sc_hd__inv_2
X_4674_ _6989_/Q _4677_/B VGND VGND VPWR VPWR _4674_/X sky130_fd_sc_hd__or2_2
X_7393_ _7404_/CLK _7393_/D _6673_/Y VGND VGND VPWR VPWR _7393_/Q sky130_fd_sc_hd__dfrtp_2
X_3625_ _3618_/X _3619_/Y _3620_/X _3624_/X VGND VGND VPWR VPWR _3625_/X sky130_fd_sc_hd__a31o_2
XFILLER_115_420 VGND VGND VPWR VPWR sky130_fd_sc_hd__decap_3
X_6344_ _6629_/A VGND VGND VPWR VPWR _6344_/Y sky130_fd_sc_hd__inv_2
X_3556_ _3556_/A _3556_/B _3556_/C VGND VGND VPWR VPWR _3556_/X sky130_fd_sc_hd__or3_2
XFILLER_0_219 VGND VGND VPWR VPWR sky130_fd_sc_hd__decap_3
XFILLER_103_615 VGND VGND VPWR VPWR sky130_fd_sc_hd__fill_1
XFILLER_103_626 VGND VGND VPWR VPWR sky130_fd_sc_hd__decap_3
XFILLER_115_464 VGND VGND VPWR VPWR sky130_fd_sc_hd__decap_3
X_6275_ _6278_/A VGND VGND VPWR VPWR _6275_/Y sky130_fd_sc_hd__inv_2
XPHY_EDGE_ROW_47_Left_164 VGND VGND VPWR VPWR sky130_fd_sc_hd__decap_3
XFILLER_102_103 VGND VGND VPWR VPWR sky130_fd_sc_hd__decap_3
XFILLER_102_136 VGND VGND VPWR VPWR sky130_fd_sc_hd__decap_3
XFILLER_103_659 VGND VGND VPWR VPWR sky130_fd_sc_hd__decap_3
XFILLER_115_497 VGND VGND VPWR VPWR sky130_fd_sc_hd__decap_3
XFILLER_88_337 VGND VGND VPWR VPWR sky130_fd_sc_hd__fill_1
XFILLER_88_348 VGND VGND VPWR VPWR sky130_fd_sc_hd__decap_3
X_3487_ _3469_/A _3469_/B _3449_/A _7247_/Q _3365_/A VGND VGND VPWR VPWR _3487_/X
+ sky130_fd_sc_hd__o2111a_2
XFILLER_29_404 VGND VGND VPWR VPWR sky130_fd_sc_hd__decap_3
XFILLER_69_573 VGND VGND VPWR VPWR sky130_fd_sc_hd__decap_3
X_5157_ _5157_/A0 _5156_/X _5157_/S VGND VGND VPWR VPWR _7248_/D sky130_fd_sc_hd__mux2_2
XFILLER_110_191 VGND VGND VPWR VPWR sky130_fd_sc_hd__decap_3
XFILLER_56_223 VGND VGND VPWR VPWR sky130_fd_sc_hd__decap_3
XFILLER_56_256 VGND VGND VPWR VPWR sky130_fd_sc_hd__decap_3
XFILLER_84_554 VGND VGND VPWR VPWR sky130_fd_sc_hd__decap_3
X_5088_ _5086_/A _4365_/X _5086_/X _5087_/Y _5020_/A VGND VGND VPWR VPWR _5088_/X
+ sky130_fd_sc_hd__a2111o_2
X_4108_ _4394_/A _4394_/B _4107_/X VGND VGND VPWR VPWR _4142_/C sky130_fd_sc_hd__or3b_2
XFILLER_112_12 VGND VGND VPWR VPWR sky130_fd_sc_hd__decap_3
XFILLER_84_587 VGND VGND VPWR VPWR sky130_fd_sc_hd__fill_1
XFILLER_84_598 VGND VGND VPWR VPWR sky130_fd_sc_hd__decap_3
X_4039_ _4039_/A _4458_/A VGND VGND VPWR VPWR _4040_/B sky130_fd_sc_hd__and2_2
XTAP_TAPCELL_ROW_55_914 VGND VPWR sky130_fd_sc_hd__tapvpwrvgnd_1
XFILLER_112_56 VGND VGND VPWR VPWR sky130_fd_sc_hd__decap_3
XFILLER_25_632 VGND VGND VPWR VPWR sky130_fd_sc_hd__decap_3
XFILLER_37_492 VGND VGND VPWR VPWR sky130_fd_sc_hd__decap_3
XFILLER_71_237 VGND VGND VPWR VPWR sky130_fd_sc_hd__decap_3
XFILLER_24_153 VGND VGND VPWR VPWR sky130_fd_sc_hd__decap_3
XFILLER_25_665 VGND VGND VPWR VPWR sky130_fd_sc_hd__decap_3
XFILLER_25_676 VGND VGND VPWR VPWR sky130_fd_sc_hd__decap_3
XFILLER_52_451 VGND VGND VPWR VPWR sky130_fd_sc_hd__decap_3
XFILLER_71_259 VGND VGND VPWR VPWR sky130_fd_sc_hd__decap_3
XFILLER_72_38 VGND VGND VPWR VPWR sky130_fd_sc_hd__decap_3
XPHY_EDGE_ROW_56_Left_173 VGND VGND VPWR VPWR sky130_fd_sc_hd__decap_3
XFILLER_12_304 VGND VGND VPWR VPWR sky130_fd_sc_hd__decap_3
XFILLER_12_315 VGND VGND VPWR VPWR sky130_fd_sc_hd__fill_2
XFILLER_40_613 VGND VGND VPWR VPWR sky130_fd_sc_hd__decap_3
XFILLER_52_473 VGND VGND VPWR VPWR sky130_fd_sc_hd__decap_3
XTAP_TAPCELL_ROW_35_671 VGND VPWR sky130_fd_sc_hd__tapvpwrvgnd_1
XFILLER_40_657 VGND VGND VPWR VPWR sky130_fd_sc_hd__decap_3
XFILLER_115_3 VGND VGND VPWR VPWR sky130_fd_sc_hd__decap_3
XFILLER_21_53 VGND VGND VPWR VPWR sky130_fd_sc_hd__decap_3
XFILLER_4_525 VGND VGND VPWR VPWR sky130_fd_sc_hd__decap_3
XFILLER_106_442 VGND VGND VPWR VPWR sky130_fd_sc_hd__decap_3
XFILLER_21_86 VGND VGND VPWR VPWR sky130_fd_sc_hd__decap_3
XFILLER_4_536 VGND VGND VPWR VPWR sky130_fd_sc_hd__decap_3
XPHY_EDGE_ROW_65_Left_182 VGND VGND VPWR VPWR sky130_fd_sc_hd__decap_3
XFILLER_106_475 VGND VGND VPWR VPWR sky130_fd_sc_hd__fill_1
XFILLER_4_569 VGND VGND VPWR VPWR sky130_fd_sc_hd__decap_3
XFILLER_106_486 VGND VGND VPWR VPWR sky130_fd_sc_hd__decap_3
XFILLER_79_337 VGND VGND VPWR VPWR sky130_fd_sc_hd__decap_3
XFILLER_97_57 VGND VGND VPWR VPWR sky130_fd_sc_hd__fill_1
XTAP_TAPCELL_ROW_7_341 VGND VPWR sky130_fd_sc_hd__tapvpwrvgnd_1
XTAP_TAPCELL_ROW_7_330 VGND VPWR sky130_fd_sc_hd__tapvpwrvgnd_1
XFILLER_102_681 VGND VGND VPWR VPWR sky130_fd_sc_hd__decap_3
XFILLER_94_318 VGND VGND VPWR VPWR sky130_fd_sc_hd__decap_3
XFILLER_35_418 VGND VGND VPWR VPWR sky130_fd_sc_hd__fill_1
XFILLER_35_429 VGND VGND VPWR VPWR sky130_fd_sc_hd__decap_3
XFILLER_47_278 VGND VGND VPWR VPWR sky130_fd_sc_hd__fill_2
XFILLER_62_215 VGND VGND VPWR VPWR sky130_fd_sc_hd__decap_3
XFILLER_75_576 VGND VGND VPWR VPWR sky130_fd_sc_hd__decap_3
XPHY_EDGE_ROW_74_Left_191 VGND VGND VPWR VPWR sky130_fd_sc_hd__decap_3
XFILLER_16_610 VGND VGND VPWR VPWR sky130_fd_sc_hd__decap_3
XFILLER_16_643 VGND VGND VPWR VPWR sky130_fd_sc_hd__fill_1
XFILLER_90_557 VGND VGND VPWR VPWR sky130_fd_sc_hd__decap_3
XFILLER_15_142 VGND VGND VPWR VPWR sky130_fd_sc_hd__fill_1
XFILLER_16_654 VGND VGND VPWR VPWR sky130_fd_sc_hd__decap_3
XFILLER_43_440 VGND VGND VPWR VPWR sky130_fd_sc_hd__decap_3
XFILLER_15_175 VGND VGND VPWR VPWR sky130_fd_sc_hd__decap_3
XFILLER_16_687 VGND VGND VPWR VPWR sky130_fd_sc_hd__decap_3
XFILLER_31_635 VGND VGND VPWR VPWR sky130_fd_sc_hd__decap_3
XFILLER_70_281 VGND VGND VPWR VPWR sky130_fd_sc_hd__decap_3
XFILLER_15_197 VGND VGND VPWR VPWR sky130_fd_sc_hd__decap_3
XFILLER_31_668 VGND VGND VPWR VPWR sky130_fd_sc_hd__decap_3
XFILLER_62_82 VGND VGND VPWR VPWR sky130_fd_sc_hd__fill_2
XFILLER_31_679 VGND VGND VPWR VPWR sky130_fd_sc_hd__decap_3
XFILLER_7_330 VGND VGND VPWR VPWR sky130_fd_sc_hd__decap_3
XTAP_TAPCELL_ROW_96_1404 VGND VPWR sky130_fd_sc_hd__tapvpwrvgnd_1
XFILLER_7_363 VGND VGND VPWR VPWR sky130_fd_sc_hd__decap_3
X_4390_ _7241_/Q _4433_/B _4390_/B1 _7209_/Q VGND VGND VPWR VPWR _4390_/X sky130_fd_sc_hd__a22o_2
X_3410_ _7219_/Q _4284_/A2 _4528_/B _7032_/Q VGND VGND VPWR VPWR _3410_/X sky130_fd_sc_hd__a22o_2
X_3341_ _3341_/A VGND VGND VPWR VPWR _5642_/A sky130_fd_sc_hd__inv_2
XFILLER_98_613 VGND VGND VPWR VPWR sky130_fd_sc_hd__decap_3
XFILLER_112_412 VGND VGND VPWR VPWR sky130_fd_sc_hd__decap_3
XFILLER_3_591 VGND VGND VPWR VPWR sky130_fd_sc_hd__decap_3
XFILLER_98_657 VGND VGND VPWR VPWR sky130_fd_sc_hd__decap_3
XFILLER_100_607 VGND VGND VPWR VPWR sky130_fd_sc_hd__decap_3
XFILLER_112_445 VGND VGND VPWR VPWR sky130_fd_sc_hd__decap_3
XFILLER_97_156 VGND VGND VPWR VPWR sky130_fd_sc_hd__decap_3
XFILLER_112_489 VGND VGND VPWR VPWR sky130_fd_sc_hd__decap_3
XFILLER_85_318 VGND VGND VPWR VPWR sky130_fd_sc_hd__decap_3
Xhold1008 _7202_/Q VGND VGND VPWR VPWR _5256_/A0 sky130_fd_sc_hd__dlygate4sd3_1
Xhold1019 _7274_/Q VGND VGND VPWR VPWR _4793_/A0 sky130_fd_sc_hd__dlygate4sd3_1
X_5011_ _5040_/S _6991_/D _5010_/X VGND VGND VPWR VPWR _5011_/X sky130_fd_sc_hd__o21a_2
XFILLER_38_267 VGND VGND VPWR VPWR sky130_fd_sc_hd__decap_3
XFILLER_66_587 VGND VGND VPWR VPWR sky130_fd_sc_hd__fill_1
XFILLER_66_598 VGND VGND VPWR VPWR sky130_fd_sc_hd__decap_3
XFILLER_93_351 VGND VGND VPWR VPWR sky130_fd_sc_hd__decap_3
XFILLER_81_557 VGND VGND VPWR VPWR sky130_fd_sc_hd__decap_3
X_6962_ _6974_/CLK _6962_/D VGND VGND VPWR VPWR _6962_/Q sky130_fd_sc_hd__dfxtp_2
XTAP_TAPCELL_ROW_105_1511 VGND VPWR sky130_fd_sc_hd__tapvpwrvgnd_1
XFILLER_81_579 VGND VGND VPWR VPWR sky130_fd_sc_hd__decap_3
X_6893_ _7403_/CLK _6893_/D VGND VGND VPWR VPWR _6893_/Q sky130_fd_sc_hd__dfxtp_2
XFILLER_22_613 VGND VGND VPWR VPWR sky130_fd_sc_hd__decap_3
XFILLER_34_495 VGND VGND VPWR VPWR sky130_fd_sc_hd__fill_1
XFILLER_21_145 VGND VGND VPWR VPWR sky130_fd_sc_hd__decap_3
XFILLER_22_657 VGND VGND VPWR VPWR sky130_fd_sc_hd__decap_3
XFILLER_61_281 VGND VGND VPWR VPWR sky130_fd_sc_hd__decap_3
XTAP_TAPCELL_ROW_32_641 VGND VPWR sky130_fd_sc_hd__tapvpwrvgnd_1
XTAP_TAPCELL_ROW_32_630 VGND VPWR sky130_fd_sc_hd__tapvpwrvgnd_1
XTAP_TAPCELL_ROW_60_972 VGND VPWR sky130_fd_sc_hd__tapvpwrvgnd_1
XFILLER_30_690 VGND VGND VPWR VPWR sky130_fd_sc_hd__fill_1
X_4726_ _4832_/A _5655_/A _3670_/X _4467_/B VGND VGND VPWR VPWR _4726_/X sky130_fd_sc_hd__o211a_2
X_4657_ _4720_/A _4655_/X _4948_/A VGND VGND VPWR VPWR _4658_/B sky130_fd_sc_hd__a21oi_2
X_7376_ _7383_/CLK _7376_/D _6656_/Y VGND VGND VPWR VPWR _7376_/Q sky130_fd_sc_hd__dfrtp_2
Xhold820 _6854_/Q VGND VGND VPWR VPWR _6854_/D sky130_fd_sc_hd__dlygate4sd3_1
XTAP_TAPCELL_ROW_116_1651 VGND VPWR sky130_fd_sc_hd__tapvpwrvgnd_1
XTAP_TAPCELL_ROW_116_1640 VGND VPWR sky130_fd_sc_hd__tapvpwrvgnd_1
XFILLER_101_9 VGND VGND VPWR VPWR sky130_fd_sc_hd__decap_3
XFILLER_107_12 VGND VGND VPWR VPWR sky130_fd_sc_hd__decap_3
XFILLER_1_517 VGND VGND VPWR VPWR sky130_fd_sc_hd__decap_3
Xhold831 _6868_/Q VGND VGND VPWR VPWR _6868_/D sky130_fd_sc_hd__dlygate4sd3_1
Xhold842 _7076_/Q VGND VGND VPWR VPWR _7076_/D sky130_fd_sc_hd__dlygate4sd3_1
Xhold853 _7087_/Q VGND VGND VPWR VPWR _7087_/D sky130_fd_sc_hd__dlygate4sd3_1
Xhold864 _7060_/Q VGND VGND VPWR VPWR _7060_/D sky130_fd_sc_hd__dlygate4sd3_1
Xmax_cap572 _6569_/A VGND VGND VPWR VPWR _6570_/A sky130_fd_sc_hd__buf_2
Xmax_cap561 _3339_/Y VGND VGND VPWR VPWR _3469_/A sky130_fd_sc_hd__buf_2
X_6327_ _6680_/A VGND VGND VPWR VPWR _6327_/Y sky130_fd_sc_hd__inv_2
XFILLER_103_423 VGND VGND VPWR VPWR sky130_fd_sc_hd__decap_3
XFILLER_107_45 VGND VGND VPWR VPWR sky130_fd_sc_hd__decap_3
XFILLER_115_272 VGND VGND VPWR VPWR sky130_fd_sc_hd__decap_3
XFILLER_88_112 VGND VGND VPWR VPWR sky130_fd_sc_hd__decap_3
XFILLER_89_635 VGND VGND VPWR VPWR sky130_fd_sc_hd__decap_3
Xhold875 _7080_/Q VGND VGND VPWR VPWR _7080_/D sky130_fd_sc_hd__dlygate4sd3_1
Xhold886 _7093_/Q VGND VGND VPWR VPWR _7093_/D sky130_fd_sc_hd__dlygate4sd3_1
Xhold897 _7062_/Q VGND VGND VPWR VPWR _7062_/D sky130_fd_sc_hd__dlygate4sd3_1
X_3539_ _3544_/A _3544_/B VGND VGND VPWR VPWR _3547_/A sky130_fd_sc_hd__nand2_2
XFILLER_103_456 VGND VGND VPWR VPWR sky130_fd_sc_hd__decap_3
XFILLER_107_67 VGND VGND VPWR VPWR sky130_fd_sc_hd__decap_3
XFILLER_88_156 VGND VGND VPWR VPWR sky130_fd_sc_hd__fill_2
XFILLER_89_668 VGND VGND VPWR VPWR sky130_fd_sc_hd__decap_3
XFILLER_89_679 VGND VGND VPWR VPWR sky130_fd_sc_hd__decap_3
XTAP_TAPCELL_ROW_4_300 VGND VPWR sky130_fd_sc_hd__tapvpwrvgnd_1
XFILLER_103_489 VGND VGND VPWR VPWR sky130_fd_sc_hd__decap_3
XFILLER_57_521 VGND VGND VPWR VPWR sky130_fd_sc_hd__fill_1
XFILLER_67_49 VGND VGND VPWR VPWR sky130_fd_sc_hd__decap_3
XFILLER_88_189 VGND VGND VPWR VPWR sky130_fd_sc_hd__decap_3
X_5209_ _5209_/A _5209_/B VGND VGND VPWR VPWR _7224_/D sky130_fd_sc_hd__and2_2
XFILLER_29_267 VGND VGND VPWR VPWR sky130_fd_sc_hd__decap_3
XFILLER_57_576 VGND VGND VPWR VPWR sky130_fd_sc_hd__decap_3
XFILLER_44_215 VGND VGND VPWR VPWR sky130_fd_sc_hd__decap_3
XFILLER_84_395 VGND VGND VPWR VPWR sky130_fd_sc_hd__decap_3
XFILLER_72_568 VGND VGND VPWR VPWR sky130_fd_sc_hd__decap_3
XFILLER_13_635 VGND VGND VPWR VPWR sky130_fd_sc_hd__decap_3
XTAP_TAPCELL_ROW_80_1216 VGND VPWR sky130_fd_sc_hd__tapvpwrvgnd_1
XFILLER_13_668 VGND VGND VPWR VPWR sky130_fd_sc_hd__decap_3
XFILLER_9_617 VGND VGND VPWR VPWR sky130_fd_sc_hd__decap_3
XFILLER_9_606 VGND VGND VPWR VPWR sky130_fd_sc_hd__decap_3
XFILLER_13_679 VGND VGND VPWR VPWR sky130_fd_sc_hd__decap_3
XFILLER_8_105 VGND VGND VPWR VPWR sky130_fd_sc_hd__fill_2
XFILLER_32_41 VGND VGND VPWR VPWR sky130_fd_sc_hd__fill_2
XFILLER_32_63 VGND VGND VPWR VPWR sky130_fd_sc_hd__fill_1
XFILLER_32_85 VGND VGND VPWR VPWR sky130_fd_sc_hd__fill_2
XTAP_TAPCELL_ROW_10_368 VGND VPWR sky130_fd_sc_hd__tapvpwrvgnd_1
XTAP_TAPCELL_ROW_78_1189 VGND VPWR sky130_fd_sc_hd__tapvpwrvgnd_1
XFILLER_106_272 VGND VGND VPWR VPWR sky130_fd_sc_hd__decap_3
XTAP_TAPCELL_ROW_91_1345 VGND VPWR sky130_fd_sc_hd__tapvpwrvgnd_1
XFILLER_79_145 VGND VGND VPWR VPWR sky130_fd_sc_hd__decap_3
XFILLER_0_572 VGND VGND VPWR VPWR sky130_fd_sc_hd__decap_3
XFILLER_79_178 VGND VGND VPWR VPWR sky130_fd_sc_hd__decap_3
XFILLER_95_638 VGND VGND VPWR VPWR sky130_fd_sc_hd__decap_3
XFILLER_88_690 VGND VGND VPWR VPWR sky130_fd_sc_hd__fill_1
XFILLER_94_137 VGND VGND VPWR VPWR sky130_fd_sc_hd__decap_3
XFILLER_48_576 VGND VGND VPWR VPWR sky130_fd_sc_hd__decap_3
XFILLER_63_513 VGND VGND VPWR VPWR sky130_fd_sc_hd__fill_2
XFILLER_35_237 VGND VGND VPWR VPWR sky130_fd_sc_hd__decap_3
XFILLER_48_598 VGND VGND VPWR VPWR sky130_fd_sc_hd__decap_3
XFILLER_90_332 VGND VGND VPWR VPWR sky130_fd_sc_hd__decap_3
XFILLER_16_440 VGND VGND VPWR VPWR sky130_fd_sc_hd__decap_3
XFILLER_63_557 VGND VGND VPWR VPWR sky130_fd_sc_hd__decap_3
XFILLER_63_579 VGND VGND VPWR VPWR sky130_fd_sc_hd__decap_3
XTAP_TAPCELL_ROW_18_468 VGND VPWR sky130_fd_sc_hd__tapvpwrvgnd_1
XFILLER_90_398 VGND VGND VPWR VPWR sky130_fd_sc_hd__decap_3
XTAP_TAPCELL_ROW_46_799 VGND VPWR sky130_fd_sc_hd__tapvpwrvgnd_1
XFILLER_43_281 VGND VGND VPWR VPWR sky130_fd_sc_hd__decap_3
X_3890_ _6963_/Q _3892_/A2 _3890_/B1 _6945_/Q VGND VGND VPWR VPWR _3890_/X sky130_fd_sc_hd__a22o_2
XFILLER_31_476 VGND VGND VPWR VPWR sky130_fd_sc_hd__decap_3
XTAP_TAPCELL_ROW_100_1452 VGND VPWR sky130_fd_sc_hd__tapvpwrvgnd_1
XFILLER_12_690 VGND VGND VPWR VPWR sky130_fd_sc_hd__fill_1
XFILLER_78_3 VGND VGND VPWR VPWR sky130_fd_sc_hd__fill_1
XFILLER_8_672 VGND VGND VPWR VPWR sky130_fd_sc_hd__decap_3
X_7230_ _7328_/CLK _7230_/D _6510_/Y VGND VGND VPWR VPWR _7230_/Q sky130_fd_sc_hd__dfrtp_2
X_4442_ _4813_/A _4827_/A VGND VGND VPWR VPWR _4779_/A sky130_fd_sc_hd__or2_2
X_7161_ _7353_/CLK _7161_/D _6441_/Y VGND VGND VPWR VPWR _7161_/Q sky130_fd_sc_hd__dfrtp_2
X_4373_ _5018_/A _5018_/B VGND VGND VPWR VPWR _4373_/Y sky130_fd_sc_hd__nand2_2
XFILLER_98_410 VGND VGND VPWR VPWR sky130_fd_sc_hd__decap_3
XFILLER_112_242 VGND VGND VPWR VPWR sky130_fd_sc_hd__decap_3
X_7092_ _7317_/CLK _7092_/D _6372_/Y VGND VGND VPWR VPWR _7092_/Q sky130_fd_sc_hd__dfrtp_2
X_3324_ _3324_/A _4467_/A _4696_/B VGND VGND VPWR VPWR _3324_/X sky130_fd_sc_hd__or3_2
XFILLER_98_454 VGND VGND VPWR VPWR sky130_fd_sc_hd__fill_1
XFILLER_100_415 VGND VGND VPWR VPWR sky130_fd_sc_hd__decap_3
XFILLER_86_616 VGND VGND VPWR VPWR sky130_fd_sc_hd__decap_3
XTAP_TAPCELL_ROW_111_1581 VGND VPWR sky130_fd_sc_hd__tapvpwrvgnd_1
XFILLER_98_498 VGND VGND VPWR VPWR sky130_fd_sc_hd__decap_3
XFILLER_39_543 VGND VGND VPWR VPWR sky130_fd_sc_hd__decap_3
XFILLER_85_148 VGND VGND VPWR VPWR sky130_fd_sc_hd__decap_3
XFILLER_39_576 VGND VGND VPWR VPWR sky130_fd_sc_hd__decap_3
XFILLER_94_660 VGND VGND VPWR VPWR sky130_fd_sc_hd__decap_3
XTAP_TAPCELL_ROW_37_700 VGND VPWR sky130_fd_sc_hd__tapvpwrvgnd_1
XFILLER_26_248 VGND VGND VPWR VPWR sky130_fd_sc_hd__decap_3
XFILLER_26_259 VGND VGND VPWR VPWR sky130_fd_sc_hd__decap_3
XFILLER_81_365 VGND VGND VPWR VPWR sky130_fd_sc_hd__decap_3
X_6945_ clkload9/A _6945_/D VGND VGND VPWR VPWR _6945_/Q sky130_fd_sc_hd__dfxtp_2
XFILLER_22_410 VGND VGND VPWR VPWR sky130_fd_sc_hd__decap_3
XFILLER_34_270 VGND VGND VPWR VPWR sky130_fd_sc_hd__decap_3
XFILLER_41_218 VGND VGND VPWR VPWR sky130_fd_sc_hd__fill_1
X_6876_ _6965_/CLK _6876_/D VGND VGND VPWR VPWR _6876_/Q sky130_fd_sc_hd__dfxtp_2
XFILLER_10_616 VGND VGND VPWR VPWR sky130_fd_sc_hd__decap_3
XFILLER_108_504 VGND VGND VPWR VPWR sky130_fd_sc_hd__decap_3
X_4709_ _7002_/Q _7003_/Q _4826_/A VGND VGND VPWR VPWR _4801_/A sky130_fd_sc_hd__and3_2
XFILLER_108_548 VGND VGND VPWR VPWR sky130_fd_sc_hd__decap_3
XFILLER_116_592 VGND VGND VPWR VPWR sky130_fd_sc_hd__decap_3
XFILLER_89_410 VGND VGND VPWR VPWR sky130_fd_sc_hd__decap_3
X_7359_ _7364_/CLK _7359_/D _6639_/Y VGND VGND VPWR VPWR _7359_/Q sky130_fd_sc_hd__dfrtp_2
Xhold650 _6916_/Q VGND VGND VPWR VPWR _6916_/D sky130_fd_sc_hd__dlygate4sd3_1
Xhold661 _6831_/Q VGND VGND VPWR VPWR _6831_/D sky130_fd_sc_hd__dlygate4sd3_1
Xhold672 _6827_/Q VGND VGND VPWR VPWR _6827_/D sky130_fd_sc_hd__dlygate4sd3_1
XFILLER_89_465 VGND VGND VPWR VPWR sky130_fd_sc_hd__fill_2
Xhold683 _6731_/Q VGND VGND VPWR VPWR _6731_/D sky130_fd_sc_hd__dlygate4sd3_1
Xhold694 _6876_/Q VGND VGND VPWR VPWR _6876_/D sky130_fd_sc_hd__dlygate4sd3_1
XFILLER_103_253 VGND VGND VPWR VPWR sky130_fd_sc_hd__decap_3
XFILLER_49_329 VGND VGND VPWR VPWR sky130_fd_sc_hd__decap_3
XFILLER_77_638 VGND VGND VPWR VPWR sky130_fd_sc_hd__decap_3
XFILLER_57_340 VGND VGND VPWR VPWR sky130_fd_sc_hd__fill_2
XFILLER_85_671 VGND VGND VPWR VPWR sky130_fd_sc_hd__fill_1
XFILLER_92_619 VGND VGND VPWR VPWR sky130_fd_sc_hd__decap_3
XFILLER_17_237 VGND VGND VPWR VPWR sky130_fd_sc_hd__decap_3
XFILLER_27_52 VGND VGND VPWR VPWR sky130_fd_sc_hd__decap_3
XFILLER_85_682 VGND VGND VPWR VPWR sky130_fd_sc_hd__decap_3
XFILLER_17_259 VGND VGND VPWR VPWR sky130_fd_sc_hd__decap_3
XFILLER_45_579 VGND VGND VPWR VPWR sky130_fd_sc_hd__decap_3
XFILLER_72_365 VGND VGND VPWR VPWR sky130_fd_sc_hd__fill_1
XFILLER_25_281 VGND VGND VPWR VPWR sky130_fd_sc_hd__decap_3
XTAP_TAPCELL_ROW_43_769 VGND VPWR sky130_fd_sc_hd__tapvpwrvgnd_1
XTAP_TAPCELL_ROW_15_427 VGND VPWR sky130_fd_sc_hd__tapvpwrvgnd_1
XFILLER_40_262 VGND VGND VPWR VPWR sky130_fd_sc_hd__decap_3
XFILLER_5_620 VGND VGND VPWR VPWR sky130_fd_sc_hd__decap_3
XFILLER_114_507 VGND VGND VPWR VPWR sky130_fd_sc_hd__decap_3
XFILLER_4_141 VGND VGND VPWR VPWR sky130_fd_sc_hd__decap_3
XFILLER_5_653 VGND VGND VPWR VPWR sky130_fd_sc_hd__decap_3
XFILLER_107_570 VGND VGND VPWR VPWR sky130_fd_sc_hd__decap_3
XFILLER_4_185 VGND VGND VPWR VPWR sky130_fd_sc_hd__decap_3
XFILLER_4_23 VGND VGND VPWR VPWR sky130_fd_sc_hd__decap_3
XFILLER_68_616 VGND VGND VPWR VPWR sky130_fd_sc_hd__decap_3
XFILLER_95_424 VGND VGND VPWR VPWR sky130_fd_sc_hd__decap_3
XFILLER_67_126 VGND VGND VPWR VPWR sky130_fd_sc_hd__fill_1
XFILLER_36_502 VGND VGND VPWR VPWR sky130_fd_sc_hd__decap_3
XFILLER_48_351 VGND VGND VPWR VPWR sky130_fd_sc_hd__fill_2
XFILLER_76_660 VGND VGND VPWR VPWR sky130_fd_sc_hd__decap_3
XFILLER_48_395 VGND VGND VPWR VPWR sky130_fd_sc_hd__decap_3
XFILLER_63_321 VGND VGND VPWR VPWR sky130_fd_sc_hd__decap_3
XFILLER_36_557 VGND VGND VPWR VPWR sky130_fd_sc_hd__decap_3
XFILLER_63_343 VGND VGND VPWR VPWR sky130_fd_sc_hd__decap_3
XFILLER_75_192 VGND VGND VPWR VPWR sky130_fd_sc_hd__decap_3
XFILLER_91_641 VGND VGND VPWR VPWR sky130_fd_sc_hd__decap_3
Xplace321 _4327_/A VGND VGND VPWR VPWR _4425_/A sky130_fd_sc_hd__buf_2
Xplace310 _3586_/Y VGND VGND VPWR VPWR _3600_/A sky130_fd_sc_hd__buf_2
XFILLER_91_685 VGND VGND VPWR VPWR sky130_fd_sc_hd__decap_3
Xplace354 _4335_/B1 VGND VGND VPWR VPWR _4351_/A2 sky130_fd_sc_hd__buf_2
Xplace343 _5425_/S VGND VGND VPWR VPWR _5409_/S sky130_fd_sc_hd__buf_2
Xplace332 _5703_/S VGND VGND VPWR VPWR _5737_/S sky130_fd_sc_hd__buf_2
X_6730_ _6970_/CLK _6730_/D VGND VGND VPWR VPWR _6730_/Q sky130_fd_sc_hd__dfxtp_2
X_4991_ _5004_/A _5004_/B _4988_/A VGND VGND VPWR VPWR _4991_/Y sky130_fd_sc_hd__a21oi_2
XFILLER_16_281 VGND VGND VPWR VPWR sky130_fd_sc_hd__fill_1
XFILLER_90_195 VGND VGND VPWR VPWR sky130_fd_sc_hd__fill_1
Xplace376 _3833_/S VGND VGND VPWR VPWR _4799_/A sky130_fd_sc_hd__buf_2
Xplace387 _5190_/B VGND VGND VPWR VPWR _5225_/B sky130_fd_sc_hd__buf_2
Xplace398 _5294_/Y VGND VGND VPWR VPWR _7412_/A sky130_fd_sc_hd__buf_2
Xplace365 _3409_/X VGND VGND VPWR VPWR _4352_/B1 sky130_fd_sc_hd__buf_2
X_6661_ _6667_/A VGND VGND VPWR VPWR _6661_/Y sky130_fd_sc_hd__inv_2
X_3873_ _3733_/X _3870_/X _3872_/X _3629_/A VGND VGND VPWR VPWR _3874_/B sky130_fd_sc_hd__a22o_2
XFILLER_31_284 VGND VGND VPWR VPWR sky130_fd_sc_hd__fill_1
X_6592_ _6633_/A VGND VGND VPWR VPWR _6592_/Y sky130_fd_sc_hd__inv_2
XFILLER_105_529 VGND VGND VPWR VPWR sky130_fd_sc_hd__decap_3
X_7213_ _7372_/CLK _7213_/D _6493_/Y VGND VGND VPWR VPWR _7213_/Q sky130_fd_sc_hd__dfrtp_2
X_4425_ _4425_/A _4649_/B _4425_/C VGND VGND VPWR VPWR _4426_/B sky130_fd_sc_hd__and3_2
XTAP_TAPCELL_ROW_113_1610 VGND VPWR sky130_fd_sc_hd__tapvpwrvgnd_1
X_7144_ _7144_/CLK _7144_/D _6424_/Y VGND VGND VPWR VPWR _7144_/Q sky130_fd_sc_hd__dfrtp_2
X_4356_ _7012_/Q _4356_/A2 _4312_/B _7353_/Q _4355_/X VGND VGND VPWR VPWR _4356_/X
+ sky130_fd_sc_hd__a221o_2
XFILLER_98_240 VGND VGND VPWR VPWR sky130_fd_sc_hd__decap_3
XFILLER_113_573 VGND VGND VPWR VPWR sky130_fd_sc_hd__decap_3
XFILLER_48_29 VGND VGND VPWR VPWR sky130_fd_sc_hd__fill_1
XFILLER_59_638 VGND VGND VPWR VPWR sky130_fd_sc_hd__decap_3
XFILLER_86_424 VGND VGND VPWR VPWR sky130_fd_sc_hd__decap_3
X_7075_ _7406_/CLK _7075_/D _6355_/Y VGND VGND VPWR VPWR _7075_/Q sky130_fd_sc_hd__dfrtp_2
X_4287_ _7286_/Q _5157_/S _3409_/X _7158_/Q VGND VGND VPWR VPWR _4288_/D sky130_fd_sc_hd__a22o_2
XFILLER_98_295 VGND VGND VPWR VPWR sky130_fd_sc_hd__decap_3
XFILLER_100_256 VGND VGND VPWR VPWR sky130_fd_sc_hd__decap_3
XFILLER_104_24 VGND VGND VPWR VPWR sky130_fd_sc_hd__decap_3
XFILLER_104_35 VGND VGND VPWR VPWR sky130_fd_sc_hd__decap_3
XFILLER_67_671 VGND VGND VPWR VPWR sky130_fd_sc_hd__fill_1
XFILLER_74_619 VGND VGND VPWR VPWR sky130_fd_sc_hd__decap_3
XFILLER_104_46 VGND VGND VPWR VPWR sky130_fd_sc_hd__decap_3
XFILLER_54_321 VGND VGND VPWR VPWR sky130_fd_sc_hd__decap_3
XFILLER_64_17 VGND VGND VPWR VPWR sky130_fd_sc_hd__decap_3
XFILLER_67_682 VGND VGND VPWR VPWR sky130_fd_sc_hd__decap_3
XFILLER_81_140 VGND VGND VPWR VPWR sky130_fd_sc_hd__decap_3
XFILLER_82_663 VGND VGND VPWR VPWR sky130_fd_sc_hd__decap_3
XFILLER_27_579 VGND VGND VPWR VPWR sky130_fd_sc_hd__decap_3
XFILLER_42_516 VGND VGND VPWR VPWR sky130_fd_sc_hd__fill_1
XFILLER_54_365 VGND VGND VPWR VPWR sky130_fd_sc_hd__decap_3
XTAP_TAPCELL_ROW_64_1019 VGND VPWR sky130_fd_sc_hd__tapvpwrvgnd_1
XFILLER_81_184 VGND VGND VPWR VPWR sky130_fd_sc_hd__decap_3
Xfanout22 fanout38/A VGND VGND VPWR VPWR _6678_/A sky130_fd_sc_hd__clkdlybuf4s25_1
X_6928_ _6943_/CLK _6928_/D VGND VGND VPWR VPWR _6928_/Q sky130_fd_sc_hd__dfxtp_2
XFILLER_50_560 VGND VGND VPWR VPWR sky130_fd_sc_hd__decap_3
Xfanout33 fanout47/X VGND VGND VPWR VPWR fanout33/X sky130_fd_sc_hd__clkdlybuf4s25_1
Xfanout44 fanout46/X VGND VGND VPWR VPWR _6608_/A sky130_fd_sc_hd__buf_2
Xfanout55 _6653_/A VGND VGND VPWR VPWR _6680_/A sky130_fd_sc_hd__buf_2
X_6859_ clkload6/A _6859_/D VGND VGND VPWR VPWR _6859_/Q sky130_fd_sc_hd__dfxtp_2
XFILLER_10_424 VGND VGND VPWR VPWR sky130_fd_sc_hd__fill_2
XFILLER_10_435 VGND VGND VPWR VPWR sky130_fd_sc_hd__decap_3
XFILLER_22_273 VGND VGND VPWR VPWR sky130_fd_sc_hd__decap_3
Xfanout66 _6557_/A VGND VGND VPWR VPWR _6651_/A sky130_fd_sc_hd__buf_2
XTAP_TAPCELL_ROW_40_728 VGND VPWR sky130_fd_sc_hd__tapvpwrvgnd_1
XFILLER_10_446 VGND VGND VPWR VPWR sky130_fd_sc_hd__decap_3
XFILLER_108_345 VGND VGND VPWR VPWR sky130_fd_sc_hd__decap_3
XFILLER_89_47 VGND VGND VPWR VPWR sky130_fd_sc_hd__fill_1
XTAP_TAPCELL_ROW_20_496 VGND VPWR sky130_fd_sc_hd__tapvpwrvgnd_1
XFILLER_2_601 VGND VGND VPWR VPWR sky130_fd_sc_hd__decap_3
XTAP_TAPCELL_ROW_75_1148 VGND VPWR sky130_fd_sc_hd__tapvpwrvgnd_1
XFILLER_2_634 VGND VGND VPWR VPWR sky130_fd_sc_hd__decap_3
XFILLER_2_645 VGND VGND VPWR VPWR sky130_fd_sc_hd__decap_3
XFILLER_104_551 VGND VGND VPWR VPWR sky130_fd_sc_hd__decap_3
XFILLER_104_584 VGND VGND VPWR VPWR sky130_fd_sc_hd__decap_3
XFILLER_2_678 VGND VGND VPWR VPWR sky130_fd_sc_hd__decap_3
XFILLER_77_413 VGND VGND VPWR VPWR sky130_fd_sc_hd__fill_2
XFILLER_104_595 VGND VGND VPWR VPWR sky130_fd_sc_hd__decap_3
XFILLER_1_177 VGND VGND VPWR VPWR sky130_fd_sc_hd__decap_3
XFILLER_89_284 VGND VGND VPWR VPWR sky130_fd_sc_hd__decap_3
XFILLER_38_40 VGND VGND VPWR VPWR sky130_fd_sc_hd__fill_1
XFILLER_58_660 VGND VGND VPWR VPWR sky130_fd_sc_hd__decap_3
XFILLER_92_427 VGND VGND VPWR VPWR sky130_fd_sc_hd__decap_3
XTAP_TAPCELL_ROW_48_828 VGND VPWR sky130_fd_sc_hd__tapvpwrvgnd_1
XFILLER_18_557 VGND VGND VPWR VPWR sky130_fd_sc_hd__decap_3
XFILLER_73_641 VGND VGND VPWR VPWR sky130_fd_sc_hd__decap_3
Xhold1180 _7309_/Q VGND VGND VPWR VPWR _4542_/A sky130_fd_sc_hd__dlygate4sd3_1
Xhold1191 _7298_/Q VGND VGND VPWR VPWR _4565_/A sky130_fd_sc_hd__dlygate4sd3_1
XFILLER_73_685 VGND VGND VPWR VPWR sky130_fd_sc_hd__decap_3
XTAP_TAPCELL_ROW_86_1288 VGND VPWR sky130_fd_sc_hd__tapvpwrvgnd_1
XFILLER_60_324 VGND VGND VPWR VPWR sky130_fd_sc_hd__decap_3
XFILLER_72_195 VGND VGND VPWR VPWR sky130_fd_sc_hd__fill_1
XTAP_TAPCELL_ROW_28_585 VGND VPWR sky130_fd_sc_hd__tapvpwrvgnd_1
XFILLER_60_368 VGND VGND VPWR VPWR sky130_fd_sc_hd__decap_3
XFILLER_60_379 VGND VGND VPWR VPWR sky130_fd_sc_hd__decap_3
XFILLER_41_582 VGND VGND VPWR VPWR sky130_fd_sc_hd__decap_3
XFILLER_13_295 VGND VGND VPWR VPWR sky130_fd_sc_hd__decap_3
XFILLER_9_266 VGND VGND VPWR VPWR sky130_fd_sc_hd__decap_3
XFILLER_62_6 VGND VGND VPWR VPWR sky130_fd_sc_hd__decap_3
XFILLER_70_82 VGND VGND VPWR VPWR sky130_fd_sc_hd__fill_2
Xclkload14 _7350_/CLK VGND VGND VPWR VPWR clkload14/X sky130_fd_sc_hd__clkbuf_1
Xclkload25 _7403_/CLK VGND VGND VPWR VPWR clkload25/X sky130_fd_sc_hd__clkbuf_1
XFILLER_9_288 VGND VGND VPWR VPWR sky130_fd_sc_hd__decap_3
XFILLER_114_304 VGND VGND VPWR VPWR sky130_fd_sc_hd__decap_3
XFILLER_5_483 VGND VGND VPWR VPWR sky130_fd_sc_hd__decap_3
XFILLER_114_348 VGND VGND VPWR VPWR sky130_fd_sc_hd__decap_3
XFILLER_114_359 VGND VGND VPWR VPWR sky130_fd_sc_hd__decap_3
XFILLER_79_80 VGND VGND VPWR VPWR sky130_fd_sc_hd__decap_3
X_4210_ _4095_/A _4210_/B VGND VGND VPWR VPWR _4210_/X sky130_fd_sc_hd__and2b_2
XPHY_EDGE_ROW_10_Left_127 VGND VGND VPWR VPWR sky130_fd_sc_hd__decap_3
X_5190_ _5190_/A _5190_/B VGND VGND VPWR VPWR _7233_/D sky130_fd_sc_hd__and2_2
XFILLER_110_510 VGND VGND VPWR VPWR sky130_fd_sc_hd__decap_3
XFILLER_95_221 VGND VGND VPWR VPWR sky130_fd_sc_hd__decap_3
X_4141_ _4141_/A _4141_/B VGND VGND VPWR VPWR _4142_/B sky130_fd_sc_hd__nor2_2
XFILLER_110_554 VGND VGND VPWR VPWR sky130_fd_sc_hd__decap_3
XFILLER_56_619 VGND VGND VPWR VPWR sky130_fd_sc_hd__decap_3
X_4072_ _7243_/Q _4430_/A2 _4459_/C1 _7179_/Q _4071_/X VGND VGND VPWR VPWR _4072_/X
+ sky130_fd_sc_hd__a221o_2
XFILLER_110_587 VGND VGND VPWR VPWR sky130_fd_sc_hd__fill_1
XFILLER_110_598 VGND VGND VPWR VPWR sky130_fd_sc_hd__decap_3
XFILLER_49_671 VGND VGND VPWR VPWR sky130_fd_sc_hd__fill_1
XFILLER_49_682 VGND VGND VPWR VPWR sky130_fd_sc_hd__decap_3
XFILLER_83_449 VGND VGND VPWR VPWR sky130_fd_sc_hd__decap_3
XFILLER_95_298 VGND VGND VPWR VPWR sky130_fd_sc_hd__fill_1
XFILLER_95_90 VGND VGND VPWR VPWR sky130_fd_sc_hd__decap_3
XFILLER_64_663 VGND VGND VPWR VPWR sky130_fd_sc_hd__decap_3
XFILLER_24_505 VGND VGND VPWR VPWR sky130_fd_sc_hd__fill_1
XFILLER_51_313 VGND VGND VPWR VPWR sky130_fd_sc_hd__decap_3
X_4974_ _6993_/Q _4983_/B VGND VGND VPWR VPWR _4975_/B sky130_fd_sc_hd__xor2_2
X_6713_ _6941_/CLK _6713_/D VGND VGND VPWR VPWR _6713_/Q sky130_fd_sc_hd__dfxtp_2
X_3925_ _6687_/Q _3925_/A2 _3925_/B1 _6865_/Q VGND VGND VPWR VPWR _3925_/X sky130_fd_sc_hd__a22o_2
XFILLER_32_582 VGND VGND VPWR VPWR sky130_fd_sc_hd__decap_3
X_6644_ _6644_/A VGND VGND VPWR VPWR _6644_/Y sky130_fd_sc_hd__inv_2
Xclkload8 clkload8/A VGND VGND VPWR VPWR clkload8/X sky130_fd_sc_hd__clkbuf_1
X_3856_ _3845_/X _3855_/X _3991_/A VGND VGND VPWR VPWR _3856_/X sky130_fd_sc_hd__o21a_2
X_6575_ _6612_/A VGND VGND VPWR VPWR _6575_/Y sky130_fd_sc_hd__inv_2
X_3787_ _6739_/Q _3891_/A2 _3852_/B1 _6745_/Q _3786_/X VGND VGND VPWR VPWR _3787_/X
+ sky130_fd_sc_hd__a221o_2
XFILLER_105_337 VGND VGND VPWR VPWR sky130_fd_sc_hd__decap_3
XFILLER_59_28 VGND VGND VPWR VPWR sky130_fd_sc_hd__fill_1
Xoutput541 _7007_/Q VGND VGND VPWR VPWR pc_out[30] sky130_fd_sc_hd__clkdlybuf4s25_1
Xoutput530 _6997_/Q VGND VGND VPWR VPWR pc_out[20] sky130_fd_sc_hd__clkdlybuf4s25_1
X_4408_ _7024_/Q _4437_/A2 _4404_/X _4407_/X VGND VGND VPWR VPWR _4409_/B sky130_fd_sc_hd__a211o_2
XFILLER_115_12 VGND VGND VPWR VPWR sky130_fd_sc_hd__decap_3
X_5388_ _5388_/A0 _4913_/X _5409_/S VGND VGND VPWR VPWR _7139_/D sky130_fd_sc_hd__mux2_2
XFILLER_99_582 VGND VGND VPWR VPWR sky130_fd_sc_hd__decap_3
XFILLER_101_532 VGND VGND VPWR VPWR sky130_fd_sc_hd__decap_3
XFILLER_113_381 VGND VGND VPWR VPWR sky130_fd_sc_hd__decap_3
XFILLER_115_45 VGND VGND VPWR VPWR sky130_fd_sc_hd__decap_3
XFILLER_59_424 VGND VGND VPWR VPWR sky130_fd_sc_hd__decap_3
XFILLER_59_435 VGND VGND VPWR VPWR sky130_fd_sc_hd__decap_3
X_7127_ _7344_/CLK _7127_/D _6407_/Y VGND VGND VPWR VPWR _7127_/Q sky130_fd_sc_hd__dfrtp_2
X_4339_ _7287_/Q _4532_/S _3366_/X _7159_/Q VGND VGND VPWR VPWR _4339_/X sky130_fd_sc_hd__a22o_2
XFILLER_101_576 VGND VGND VPWR VPWR sky130_fd_sc_hd__decap_3
XFILLER_115_78 VGND VGND VPWR VPWR sky130_fd_sc_hd__decap_3
X_7058_ _7311_/CLK _7058_/D _6338_/Y VGND VGND VPWR VPWR _7058_/Q sky130_fd_sc_hd__dfstp_2
XTAP_TAPCELL_ROW_70_1089 VGND VPWR sky130_fd_sc_hd__tapvpwrvgnd_1
XFILLER_46_118 VGND VGND VPWR VPWR sky130_fd_sc_hd__decap_3
XFILLER_74_416 VGND VGND VPWR VPWR sky130_fd_sc_hd__decap_3
XFILLER_74_438 VGND VGND VPWR VPWR sky130_fd_sc_hd__fill_2
XFILLER_27_332 VGND VGND VPWR VPWR sky130_fd_sc_hd__decap_3
XFILLER_55_641 VGND VGND VPWR VPWR sky130_fd_sc_hd__decap_3
XFILLER_15_505 VGND VGND VPWR VPWR sky130_fd_sc_hd__fill_1
XFILLER_27_376 VGND VGND VPWR VPWR sky130_fd_sc_hd__decap_3
XFILLER_55_685 VGND VGND VPWR VPWR sky130_fd_sc_hd__decap_3
XFILLER_91_15 VGND VGND VPWR VPWR sky130_fd_sc_hd__decap_3
XFILLER_15_538 VGND VGND VPWR VPWR sky130_fd_sc_hd__decap_3
XFILLER_70_622 VGND VGND VPWR VPWR sky130_fd_sc_hd__decap_3
XFILLER_82_482 VGND VGND VPWR VPWR sky130_fd_sc_hd__fill_1
XFILLER_30_508 VGND VGND VPWR VPWR sky130_fd_sc_hd__decap_3
XFILLER_42_368 VGND VGND VPWR VPWR sky130_fd_sc_hd__decap_3
XFILLER_70_666 VGND VGND VPWR VPWR sky130_fd_sc_hd__decap_3
XTAP_TAPCELL_ROW_25_555 VGND VPWR sky130_fd_sc_hd__tapvpwrvgnd_1
XFILLER_23_582 VGND VGND VPWR VPWR sky130_fd_sc_hd__decap_3
XTAP_TAPCELL_ROW_53_886 VGND VPWR sky130_fd_sc_hd__tapvpwrvgnd_1
XFILLER_10_221 VGND VGND VPWR VPWR sky130_fd_sc_hd__decap_3
XFILLER_10_243 VGND VGND VPWR VPWR sky130_fd_sc_hd__decap_3
XFILLER_109_632 VGND VGND VPWR VPWR sky130_fd_sc_hd__decap_3
XFILLER_109_665 VGND VGND VPWR VPWR sky130_fd_sc_hd__decap_3
XFILLER_109_676 VGND VGND VPWR VPWR sky130_fd_sc_hd__decap_3
XFILLER_40_96 VGND VGND VPWR VPWR sky130_fd_sc_hd__decap_3
XFILLER_97_508 VGND VGND VPWR VPWR sky130_fd_sc_hd__decap_3
XFILLER_2_442 VGND VGND VPWR VPWR sky130_fd_sc_hd__decap_3
XFILLER_2_464 VGND VGND VPWR VPWR sky130_fd_sc_hd__decap_3
XFILLER_2_486 VGND VGND VPWR VPWR sky130_fd_sc_hd__decap_3
XFILLER_77_210 VGND VGND VPWR VPWR sky130_fd_sc_hd__decap_3
XFILLER_38_619 VGND VGND VPWR VPWR sky130_fd_sc_hd__decap_3
XFILLER_65_405 VGND VGND VPWR VPWR sky130_fd_sc_hd__decap_3
XFILLER_77_265 VGND VGND VPWR VPWR sky130_fd_sc_hd__decap_3
XTAP_TAPCELL_ROW_88_1306 VGND VPWR sky130_fd_sc_hd__tapvpwrvgnd_1
XFILLER_65_427 VGND VGND VPWR VPWR sky130_fd_sc_hd__decap_3
XFILLER_77_287 VGND VGND VPWR VPWR sky130_fd_sc_hd__fill_2
XFILLER_92_224 VGND VGND VPWR VPWR sky130_fd_sc_hd__decap_3
XFILLER_1_57 VGND VGND VPWR VPWR sky130_fd_sc_hd__fill_2
XFILLER_65_449 VGND VGND VPWR VPWR sky130_fd_sc_hd__decap_3
XFILLER_18_354 VGND VGND VPWR VPWR sky130_fd_sc_hd__fill_1
XFILLER_18_365 VGND VGND VPWR VPWR sky130_fd_sc_hd__decap_3
XFILLER_33_302 VGND VGND VPWR VPWR sky130_fd_sc_hd__decap_3
XFILLER_46_663 VGND VGND VPWR VPWR sky130_fd_sc_hd__decap_3
XFILLER_61_600 VGND VGND VPWR VPWR sky130_fd_sc_hd__decap_3
XFILLER_65_93 VGND VGND VPWR VPWR sky130_fd_sc_hd__fill_1
XFILLER_45_184 VGND VGND VPWR VPWR sky130_fd_sc_hd__decap_3
XFILLER_61_644 VGND VGND VPWR VPWR sky130_fd_sc_hd__decap_3
XFILLER_73_493 VGND VGND VPWR VPWR sky130_fd_sc_hd__fill_2
XFILLER_21_508 VGND VGND VPWR VPWR sky130_fd_sc_hd__decap_3
XFILLER_33_357 VGND VGND VPWR VPWR sky130_fd_sc_hd__decap_3
XFILLER_61_688 VGND VGND VPWR VPWR sky130_fd_sc_hd__decap_3
XFILLER_14_560 VGND VGND VPWR VPWR sky130_fd_sc_hd__decap_3
X_3710_ hold981/X _4832_/A _3709_/X VGND VGND VPWR VPWR _7399_/D sky130_fd_sc_hd__o21a_2
X_4690_ _7005_/Q _5622_/B VGND VGND VPWR VPWR _4757_/A sky130_fd_sc_hd__and2_2
XTAP_TAPCELL_ROW_99_1435 VGND VPWR sky130_fd_sc_hd__tapvpwrvgnd_1
X_6360_ _6680_/A VGND VGND VPWR VPWR _6360_/Y sky130_fd_sc_hd__inv_2
X_3572_ _4295_/B _3607_/B VGND VGND VPWR VPWR _4292_/A sky130_fd_sc_hd__xnor2_2
XFILLER_115_635 VGND VGND VPWR VPWR sky130_fd_sc_hd__decap_3
XFILLER_114_112 VGND VGND VPWR VPWR sky130_fd_sc_hd__decap_3
XFILLER_114_123 VGND VGND VPWR VPWR sky130_fd_sc_hd__decap_3
XFILLER_115_668 VGND VGND VPWR VPWR sky130_fd_sc_hd__decap_3
X_6291_ _6635_/A VGND VGND VPWR VPWR _6291_/Y sky130_fd_sc_hd__inv_2
XFILLER_114_156 VGND VGND VPWR VPWR sky130_fd_sc_hd__decap_3
XFILLER_115_679 VGND VGND VPWR VPWR sky130_fd_sc_hd__decap_3
XFILLER_88_519 VGND VGND VPWR VPWR sky130_fd_sc_hd__decap_3
XFILLER_68_221 VGND VGND VPWR VPWR sky130_fd_sc_hd__decap_3
XFILLER_96_530 VGND VGND VPWR VPWR sky130_fd_sc_hd__fill_2
X_5173_ _5173_/A _5177_/B VGND VGND VPWR VPWR _7241_/D sky130_fd_sc_hd__and2_2
XFILLER_96_563 VGND VGND VPWR VPWR sky130_fd_sc_hd__decap_3
X_4124_ _4117_/Y _4124_/B VGND VGND VPWR VPWR _4126_/A sky130_fd_sc_hd__and2b_2
XFILLER_56_416 VGND VGND VPWR VPWR sky130_fd_sc_hd__decap_3
XFILLER_68_298 VGND VGND VPWR VPWR sky130_fd_sc_hd__decap_3
XFILLER_37_641 VGND VGND VPWR VPWR sky130_fd_sc_hd__decap_3
X_4055_ _4055_/A _4658_/A VGND VGND VPWR VPWR _4720_/A sky130_fd_sc_hd__nor2b_2
XFILLER_37_685 VGND VGND VPWR VPWR sky130_fd_sc_hd__decap_3
XFILLER_71_408 VGND VGND VPWR VPWR sky130_fd_sc_hd__decap_3
XFILLER_83_279 VGND VGND VPWR VPWR sky130_fd_sc_hd__fill_1
XTAP_TAPCELL_ROW_108_1553 VGND VPWR sky130_fd_sc_hd__tapvpwrvgnd_1
XTAP_TAPCELL_ROW_108_1542 VGND VPWR sky130_fd_sc_hd__tapvpwrvgnd_1
XFILLER_24_335 VGND VGND VPWR VPWR sky130_fd_sc_hd__decap_3
XFILLER_52_622 VGND VGND VPWR VPWR sky130_fd_sc_hd__decap_3
XFILLER_12_508 VGND VGND VPWR VPWR sky130_fd_sc_hd__fill_1
XFILLER_24_368 VGND VGND VPWR VPWR sky130_fd_sc_hd__decap_3
XFILLER_52_666 VGND VGND VPWR VPWR sky130_fd_sc_hd__decap_3
XFILLER_61_18 VGND VGND VPWR VPWR sky130_fd_sc_hd__decap_3
X_4957_ _4982_/B _5009_/A _6992_/Q VGND VGND VPWR VPWR _4983_/B sky130_fd_sc_hd__o21ai_2
XTAP_TAPCELL_ROW_22_514 VGND VPWR sky130_fd_sc_hd__tapvpwrvgnd_1
X_4888_ _4888_/A _4888_/B VGND VGND VPWR VPWR _4889_/B sky130_fd_sc_hd__or2_2
X_3908_ _3728_/B _3907_/X _3991_/A VGND VGND VPWR VPWR _3908_/X sky130_fd_sc_hd__o21a_2
XTAP_TAPCELL_ROW_50_856 VGND VPWR sky130_fd_sc_hd__tapvpwrvgnd_1
XFILLER_20_563 VGND VGND VPWR VPWR sky130_fd_sc_hd__decap_3
X_6627_ _6628_/A VGND VGND VPWR VPWR _6627_/Y sky130_fd_sc_hd__inv_2
X_3839_ _3746_/X _3836_/X _3838_/X _3733_/X VGND VGND VPWR VPWR _3845_/A sky130_fd_sc_hd__a22o_2
X_6558_ _6558_/A VGND VGND VPWR VPWR _6558_/Y sky130_fd_sc_hd__inv_2
XFILLER_106_613 VGND VGND VPWR VPWR sky130_fd_sc_hd__decap_3
XFILLER_3_217 VGND VGND VPWR VPWR sky130_fd_sc_hd__decap_3
XFILLER_106_657 VGND VGND VPWR VPWR sky130_fd_sc_hd__decap_3
XFILLER_3_239 VGND VGND VPWR VPWR sky130_fd_sc_hd__decap_3
X_6489_ _6649_/A VGND VGND VPWR VPWR _6489_/Y sky130_fd_sc_hd__inv_2
XFILLER_105_167 VGND VGND VPWR VPWR sky130_fd_sc_hd__fill_1
XFILLER_10_88 VGND VGND VPWR VPWR sky130_fd_sc_hd__decap_3
XTAP_TAPCELL_ROW_72_1118 VGND VPWR sky130_fd_sc_hd__tapvpwrvgnd_1
XFILLER_114_690 VGND VGND VPWR VPWR sky130_fd_sc_hd__fill_1
XFILLER_59_210 VGND VGND VPWR VPWR sky130_fd_sc_hd__decap_3
XFILLER_101_340 VGND VGND VPWR VPWR sky130_fd_sc_hd__decap_3
XFILLER_59_254 VGND VGND VPWR VPWR sky130_fd_sc_hd__decap_3
XFILLER_86_59 VGND VGND VPWR VPWR sky130_fd_sc_hd__fill_2
XFILLER_87_552 VGND VGND VPWR VPWR sky130_fd_sc_hd__decap_3
XFILLER_47_405 VGND VGND VPWR VPWR sky130_fd_sc_hd__fill_1
XFILLER_59_265 VGND VGND VPWR VPWR sky130_fd_sc_hd__decap_3
XFILLER_59_287 VGND VGND VPWR VPWR sky130_fd_sc_hd__decap_3
XFILLER_87_585 VGND VGND VPWR VPWR sky130_fd_sc_hd__decap_3
XFILLER_47_449 VGND VGND VPWR VPWR sky130_fd_sc_hd__decap_3
XFILLER_74_224 VGND VGND VPWR VPWR sky130_fd_sc_hd__decap_3
Xclkbuf_leaf_39_clk clkbuf_leaf_1_clk/A VGND VGND VPWR VPWR clkload8/A sky130_fd_sc_hd__clkbuf_16
XTAP_TAPCELL_ROW_58_945 VGND VPWR sky130_fd_sc_hd__tapvpwrvgnd_1
XFILLER_27_140 VGND VGND VPWR VPWR sky130_fd_sc_hd__decap_3
XFILLER_28_663 VGND VGND VPWR VPWR sky130_fd_sc_hd__decap_3
XFILLER_43_600 VGND VGND VPWR VPWR sky130_fd_sc_hd__decap_3
XFILLER_74_268 VGND VGND VPWR VPWR sky130_fd_sc_hd__decap_3
XTAP_TAPCELL_ROW_2_272 VGND VPWR sky130_fd_sc_hd__tapvpwrvgnd_1
XFILLER_43_644 VGND VGND VPWR VPWR sky130_fd_sc_hd__decap_3
XFILLER_15_346 VGND VGND VPWR VPWR sky130_fd_sc_hd__decap_3
XTAP_TAPCELL_ROW_83_1247 VGND VPWR sky130_fd_sc_hd__tapvpwrvgnd_1
XFILLER_30_305 VGND VGND VPWR VPWR sky130_fd_sc_hd__decap_3
XFILLER_35_96 VGND VGND VPWR VPWR sky130_fd_sc_hd__fill_2
XFILLER_43_688 VGND VGND VPWR VPWR sky130_fd_sc_hd__decap_3
XFILLER_11_541 VGND VGND VPWR VPWR sky130_fd_sc_hd__decap_3
XFILLER_11_585 VGND VGND VPWR VPWR sky130_fd_sc_hd__decap_3
XFILLER_7_523 VGND VGND VPWR VPWR sky130_fd_sc_hd__decap_3
XFILLER_7_556 VGND VGND VPWR VPWR sky130_fd_sc_hd__decap_3
XFILLER_7_567 VGND VGND VPWR VPWR sky130_fd_sc_hd__decap_3
XFILLER_109_473 VGND VGND VPWR VPWR sky130_fd_sc_hd__decap_3
XFILLER_112_616 VGND VGND VPWR VPWR sky130_fd_sc_hd__decap_3
XTAP_TAPCELL_ROW_94_1376 VGND VPWR sky130_fd_sc_hd__tapvpwrvgnd_1
XFILLER_2_272 VGND VGND VPWR VPWR sky130_fd_sc_hd__decap_3
XFILLER_97_349 VGND VGND VPWR VPWR sky130_fd_sc_hd__decap_3
XFILLER_78_563 VGND VGND VPWR VPWR sky130_fd_sc_hd__decap_3
XFILLER_93_500 VGND VGND VPWR VPWR sky130_fd_sc_hd__fill_1
XFILLER_93_511 VGND VGND VPWR VPWR sky130_fd_sc_hd__decap_3
XFILLER_19_641 VGND VGND VPWR VPWR sky130_fd_sc_hd__decap_3
XFILLER_93_544 VGND VGND VPWR VPWR sky130_fd_sc_hd__decap_3
XFILLER_19_685 VGND VGND VPWR VPWR sky130_fd_sc_hd__decap_3
XFILLER_53_419 VGND VGND VPWR VPWR sky130_fd_sc_hd__decap_3
XFILLER_65_279 VGND VGND VPWR VPWR sky130_fd_sc_hd__fill_1
XFILLER_93_588 VGND VGND VPWR VPWR sky130_fd_sc_hd__decap_3
XFILLER_34_622 VGND VGND VPWR VPWR sky130_fd_sc_hd__decap_3
XFILLER_33_121 VGND VGND VPWR VPWR sky130_fd_sc_hd__fill_2
XFILLER_33_143 VGND VGND VPWR VPWR sky130_fd_sc_hd__fill_2
XFILLER_34_666 VGND VGND VPWR VPWR sky130_fd_sc_hd__decap_3
XFILLER_61_452 VGND VGND VPWR VPWR sky130_fd_sc_hd__decap_3
XFILLER_73_290 VGND VGND VPWR VPWR sky130_fd_sc_hd__decap_3
X_4811_ _4652_/B _4811_/B _4811_/C VGND VGND VPWR VPWR _4811_/X sky130_fd_sc_hd__and3b_2
XFILLER_21_327 VGND VGND VPWR VPWR sky130_fd_sc_hd__decap_3
XFILLER_33_165 VGND VGND VPWR VPWR sky130_fd_sc_hd__decap_3
XFILLER_33_176 VGND VGND VPWR VPWR sky130_fd_sc_hd__decap_3
X_4742_ _4745_/A _4081_/X _4454_/X _4969_/B VGND VGND VPWR VPWR _4742_/Y sky130_fd_sc_hd__o211ai_2
XTAP_TAPCELL_ROW_103_1483 VGND VPWR sky130_fd_sc_hd__tapvpwrvgnd_1
X_4673_ _4982_/B _4673_/B VGND VGND VPWR VPWR _4680_/A sky130_fd_sc_hd__or2_2
X_6412_ _6644_/A VGND VGND VPWR VPWR _6412_/Y sky130_fd_sc_hd__inv_2
X_3624_ _5114_/A _3600_/A _4614_/C _3635_/B VGND VGND VPWR VPWR _3624_/X sky130_fd_sc_hd__a22o_2
X_7392_ _7392_/CLK _7392_/D _6672_/Y VGND VGND VPWR VPWR _7392_/Q sky130_fd_sc_hd__dfrtp_2
XFILLER_115_432 VGND VGND VPWR VPWR sky130_fd_sc_hd__decap_3
X_6343_ _6629_/A VGND VGND VPWR VPWR _6343_/Y sky130_fd_sc_hd__inv_2
X_3555_ _7285_/Q _4300_/B _3366_/X _7157_/Q VGND VGND VPWR VPWR _3556_/C sky130_fd_sc_hd__a22o_2
XFILLER_115_476 VGND VGND VPWR VPWR sky130_fd_sc_hd__decap_3
X_6274_ _6278_/A VGND VGND VPWR VPWR _6274_/Y sky130_fd_sc_hd__inv_2
X_3486_ _3502_/A _3502_/B _3485_/C VGND VGND VPWR VPWR _5144_/B sky130_fd_sc_hd__o21ai_2
XFILLER_102_115 VGND VGND VPWR VPWR sky130_fd_sc_hd__decap_3
XFILLER_103_638 VGND VGND VPWR VPWR sky130_fd_sc_hd__decap_3
X_5225_ _5225_/A _5225_/B VGND VGND VPWR VPWR _7216_/D sky130_fd_sc_hd__and2_2
XFILLER_69_541 VGND VGND VPWR VPWR sky130_fd_sc_hd__decap_3
XFILLER_111_671 VGND VGND VPWR VPWR sky130_fd_sc_hd__fill_1
XFILLER_111_682 VGND VGND VPWR VPWR sky130_fd_sc_hd__decap_3
XFILLER_29_416 VGND VGND VPWR VPWR sky130_fd_sc_hd__decap_3
XFILLER_56_18 VGND VGND VPWR VPWR sky130_fd_sc_hd__decap_3
XFILLER_56_29 VGND VGND VPWR VPWR sky130_fd_sc_hd__decap_3
XFILLER_69_585 VGND VGND VPWR VPWR sky130_fd_sc_hd__decap_3
X_5156_ _7010_/D _5155_/X _5156_/S VGND VGND VPWR VPWR _5156_/X sky130_fd_sc_hd__mux2_2
XFILLER_29_449 VGND VGND VPWR VPWR sky130_fd_sc_hd__fill_1
XFILLER_84_533 VGND VGND VPWR VPWR sky130_fd_sc_hd__decap_3
X_5087_ _5101_/B _5100_/B _5086_/A _4365_/X VGND VGND VPWR VPWR _5087_/Y sky130_fd_sc_hd__a211oi_2
X_4107_ _7301_/Q _4946_/S _4351_/A2 _7109_/Q _4106_/X VGND VGND VPWR VPWR _4107_/X
+ sky130_fd_sc_hd__a221o_2
XFILLER_112_24 VGND VGND VPWR VPWR sky130_fd_sc_hd__decap_3
XFILLER_25_600 VGND VGND VPWR VPWR sky130_fd_sc_hd__decap_3
XFILLER_37_460 VGND VGND VPWR VPWR sky130_fd_sc_hd__decap_3
XFILLER_44_419 VGND VGND VPWR VPWR sky130_fd_sc_hd__fill_1
XFILLER_56_279 VGND VGND VPWR VPWR sky130_fd_sc_hd__decap_3
XFILLER_84_566 VGND VGND VPWR VPWR sky130_fd_sc_hd__decap_3
X_4038_ _4039_/A _4458_/A VGND VGND VPWR VPWR _4608_/B sky130_fd_sc_hd__nor2_2
XTAP_TAPCELL_ROW_55_915 VGND VPWR sky130_fd_sc_hd__tapvpwrvgnd_1
XFILLER_112_35 VGND VGND VPWR VPWR sky130_fd_sc_hd__decap_3
XFILLER_112_68 VGND VGND VPWR VPWR sky130_fd_sc_hd__decap_3
XFILLER_25_644 VGND VGND VPWR VPWR sky130_fd_sc_hd__decap_3
XFILLER_71_216 VGND VGND VPWR VPWR sky130_fd_sc_hd__decap_3
XTAP_TAPCELL_ROW_69_1080 VGND VPWR sky130_fd_sc_hd__tapvpwrvgnd_1
XFILLER_52_430 VGND VGND VPWR VPWR sky130_fd_sc_hd__decap_3
XFILLER_24_165 VGND VGND VPWR VPWR sky130_fd_sc_hd__decap_3
XFILLER_24_187 VGND VGND VPWR VPWR sky130_fd_sc_hd__fill_1
XFILLER_25_688 VGND VGND VPWR VPWR sky130_fd_sc_hd__decap_3
XFILLER_40_625 VGND VGND VPWR VPWR sky130_fd_sc_hd__decap_3
XFILLER_52_463 VGND VGND VPWR VPWR sky130_fd_sc_hd__fill_2
XTAP_TAPCELL_ROW_35_672 VGND VPWR sky130_fd_sc_hd__tapvpwrvgnd_1
XFILLER_40_669 VGND VGND VPWR VPWR sky130_fd_sc_hd__decap_3
XFILLER_8_309 VGND VGND VPWR VPWR sky130_fd_sc_hd__decap_3
XFILLER_4_504 VGND VGND VPWR VPWR sky130_fd_sc_hd__decap_3
XFILLER_106_410 VGND VGND VPWR VPWR sky130_fd_sc_hd__fill_2
XFILLER_108_3 VGND VGND VPWR VPWR sky130_fd_sc_hd__decap_3
XFILLER_4_548 VGND VGND VPWR VPWR sky130_fd_sc_hd__decap_3
XFILLER_106_454 VGND VGND VPWR VPWR sky130_fd_sc_hd__decap_3
XFILLER_79_305 VGND VGND VPWR VPWR sky130_fd_sc_hd__fill_1
XFILLER_106_498 VGND VGND VPWR VPWR sky130_fd_sc_hd__decap_3
XFILLER_79_349 VGND VGND VPWR VPWR sky130_fd_sc_hd__decap_3
XTAP_TAPCELL_ROW_7_331 VGND VPWR sky130_fd_sc_hd__tapvpwrvgnd_1
XFILLER_102_660 VGND VGND VPWR VPWR sky130_fd_sc_hd__decap_3
XFILLER_101_192 VGND VGND VPWR VPWR sky130_fd_sc_hd__fill_1
XFILLER_75_544 VGND VGND VPWR VPWR sky130_fd_sc_hd__decap_3
XFILLER_47_257 VGND VGND VPWR VPWR sky130_fd_sc_hd__decap_3
XFILLER_75_588 VGND VGND VPWR VPWR sky130_fd_sc_hd__decap_3
XFILLER_16_622 VGND VGND VPWR VPWR sky130_fd_sc_hd__decap_3
XFILLER_28_471 VGND VGND VPWR VPWR sky130_fd_sc_hd__decap_3
XFILLER_62_238 VGND VGND VPWR VPWR sky130_fd_sc_hd__decap_3
XFILLER_90_536 VGND VGND VPWR VPWR sky130_fd_sc_hd__decap_3
XFILLER_16_666 VGND VGND VPWR VPWR sky130_fd_sc_hd__decap_3
XFILLER_55_290 VGND VGND VPWR VPWR sky130_fd_sc_hd__decap_3
XFILLER_90_569 VGND VGND VPWR VPWR sky130_fd_sc_hd__decap_3
XFILLER_15_165 VGND VGND VPWR VPWR sky130_fd_sc_hd__decap_3
XFILLER_31_603 VGND VGND VPWR VPWR sky130_fd_sc_hd__decap_3
XFILLER_43_463 VGND VGND VPWR VPWR sky130_fd_sc_hd__decap_3
XFILLER_43_474 VGND VGND VPWR VPWR sky130_fd_sc_hd__decap_3
XFILLER_94_9 VGND VGND VPWR VPWR sky130_fd_sc_hd__decap_3
XFILLER_31_647 VGND VGND VPWR VPWR sky130_fd_sc_hd__decap_3
XFILLER_70_293 VGND VGND VPWR VPWR sky130_fd_sc_hd__decap_3
XFILLER_11_360 VGND VGND VPWR VPWR sky130_fd_sc_hd__fill_1
XFILLER_11_393 VGND VGND VPWR VPWR sky130_fd_sc_hd__decap_3
XTAP_TAPCELL_ROW_96_1405 VGND VPWR sky130_fd_sc_hd__tapvpwrvgnd_1
XFILLER_7_375 VGND VGND VPWR VPWR sky130_fd_sc_hd__fill_2
XFILLER_109_281 VGND VGND VPWR VPWR sky130_fd_sc_hd__decap_3
XFILLER_7_386 VGND VGND VPWR VPWR sky130_fd_sc_hd__decap_3
XFILLER_7_397 VGND VGND VPWR VPWR sky130_fd_sc_hd__decap_3
X_3340_ _6982_/Q _3340_/B _3340_/C VGND VGND VPWR VPWR _5640_/B sky130_fd_sc_hd__and3_2
XFILLER_112_424 VGND VGND VPWR VPWR sky130_fd_sc_hd__decap_3
XFILLER_3_570 VGND VGND VPWR VPWR sky130_fd_sc_hd__decap_3
XFILLER_98_625 VGND VGND VPWR VPWR sky130_fd_sc_hd__decap_3
XFILLER_112_457 VGND VGND VPWR VPWR sky130_fd_sc_hd__decap_3
X_5010_ _5010_/A _5662_/A _5010_/C _5010_/D VGND VGND VPWR VPWR _5010_/X sky130_fd_sc_hd__or4_2
XFILLER_98_669 VGND VGND VPWR VPWR sky130_fd_sc_hd__decap_3
XFILLER_100_619 VGND VGND VPWR VPWR sky130_fd_sc_hd__decap_3
Xhold1009 _7187_/Q VGND VGND VPWR VPWR _5284_/A0 sky130_fd_sc_hd__dlygate4sd3_1
XFILLER_38_235 VGND VGND VPWR VPWR sky130_fd_sc_hd__decap_3
XFILLER_26_408 VGND VGND VPWR VPWR sky130_fd_sc_hd__decap_3
XFILLER_38_279 VGND VGND VPWR VPWR sky130_fd_sc_hd__decap_3
XFILLER_66_566 VGND VGND VPWR VPWR sky130_fd_sc_hd__decap_3
XFILLER_81_503 VGND VGND VPWR VPWR sky130_fd_sc_hd__fill_1
XFILLER_53_216 VGND VGND VPWR VPWR sky130_fd_sc_hd__decap_3
XFILLER_81_536 VGND VGND VPWR VPWR sky130_fd_sc_hd__decap_3
XFILLER_93_385 VGND VGND VPWR VPWR sky130_fd_sc_hd__decap_3
XFILLER_93_396 VGND VGND VPWR VPWR sky130_fd_sc_hd__decap_3
X_6961_ _6970_/CLK _6961_/D VGND VGND VPWR VPWR _6961_/Q sky130_fd_sc_hd__dfxtp_2
XTAP_TAPCELL_ROW_105_1512 VGND VPWR sky130_fd_sc_hd__tapvpwrvgnd_1
XFILLER_46_290 VGND VGND VPWR VPWR sky130_fd_sc_hd__decap_3
X_6892_ _6941_/CLK _6892_/D VGND VGND VPWR VPWR _6892_/Q sky130_fd_sc_hd__dfxtp_2
XFILLER_22_625 VGND VGND VPWR VPWR sky130_fd_sc_hd__decap_3
XFILLER_34_463 VGND VGND VPWR VPWR sky130_fd_sc_hd__decap_3
XFILLER_21_113 VGND VGND VPWR VPWR sky130_fd_sc_hd__decap_3
XFILLER_22_669 VGND VGND VPWR VPWR sky130_fd_sc_hd__decap_3
XFILLER_61_293 VGND VGND VPWR VPWR sky130_fd_sc_hd__decap_3
XTAP_TAPCELL_ROW_32_631 VGND VPWR sky130_fd_sc_hd__tapvpwrvgnd_1
XTAP_TAPCELL_ROW_60_973 VGND VPWR sky130_fd_sc_hd__tapvpwrvgnd_1
X_4725_ _4969_/B _4720_/X _4723_/X _4724_/X VGND VGND VPWR VPWR _5655_/A sky130_fd_sc_hd__a211o_2
XFILLER_107_207 VGND VGND VPWR VPWR sky130_fd_sc_hd__decap_3
X_7375_ clkload7/A _7375_/D _6655_/Y VGND VGND VPWR VPWR _7375_/Q sky130_fd_sc_hd__dfrtp_2
Xhold810 _6777_/Q VGND VGND VPWR VPWR _6777_/D sky130_fd_sc_hd__dlygate4sd3_1
Xhold821 _6761_/Q VGND VGND VPWR VPWR _6761_/D sky130_fd_sc_hd__dlygate4sd3_1
X_4587_ _4587_/A _4595_/B VGND VGND VPWR VPWR _7287_/D sky130_fd_sc_hd__and2_2
X_3607_ _4295_/B _3607_/B VGND VGND VPWR VPWR _3610_/A sky130_fd_sc_hd__nand2_2
XTAP_TAPCELL_ROW_116_1652 VGND VPWR sky130_fd_sc_hd__tapvpwrvgnd_1
XTAP_TAPCELL_ROW_116_1641 VGND VPWR sky130_fd_sc_hd__tapvpwrvgnd_1
XPHY_EDGE_ROW_2_Left_119 VGND VGND VPWR VPWR sky130_fd_sc_hd__decap_3
XFILLER_89_603 VGND VGND VPWR VPWR sky130_fd_sc_hd__decap_3
Xhold832 _6836_/Q VGND VGND VPWR VPWR _6836_/D sky130_fd_sc_hd__dlygate4sd3_1
Xhold843 _7089_/Q VGND VGND VPWR VPWR _7089_/D sky130_fd_sc_hd__dlygate4sd3_1
Xhold854 _7066_/Q VGND VGND VPWR VPWR _7066_/D sky130_fd_sc_hd__dlygate4sd3_1
Xmax_cap562 _5229_/C VGND VGND VPWR VPWR _4279_/B1 sky130_fd_sc_hd__buf_2
Xmax_cap551 _4397_/Y VGND VGND VPWR VPWR _4795_/A sky130_fd_sc_hd__buf_2
X_6326_ _6680_/A VGND VGND VPWR VPWR _6326_/Y sky130_fd_sc_hd__inv_2
X_3538_ _3424_/S _3456_/X _4289_/A _3421_/C VGND VGND VPWR VPWR _3544_/B sky130_fd_sc_hd__o2bb2a_2
XFILLER_107_24 VGND VGND VPWR VPWR sky130_fd_sc_hd__decap_3
XFILLER_107_57 VGND VGND VPWR VPWR sky130_fd_sc_hd__decap_3
XFILLER_1_529 VGND VGND VPWR VPWR sky130_fd_sc_hd__decap_3
XFILLER_88_124 VGND VGND VPWR VPWR sky130_fd_sc_hd__decap_3
XFILLER_89_647 VGND VGND VPWR VPWR sky130_fd_sc_hd__decap_3
Xhold865 _7059_/Q VGND VGND VPWR VPWR _7059_/D sky130_fd_sc_hd__dlygate4sd3_1
Xhold876 _7067_/Q VGND VGND VPWR VPWR _7067_/D sky130_fd_sc_hd__dlygate4sd3_1
Xhold887 _7101_/Q VGND VGND VPWR VPWR _7101_/D sky130_fd_sc_hd__dlygate4sd3_1
Xhold898 _7075_/Q VGND VGND VPWR VPWR _7075_/D sky130_fd_sc_hd__dlygate4sd3_1
Xmax_cap573 _6537_/A VGND VGND VPWR VPWR _6542_/A sky130_fd_sc_hd__buf_2
XFILLER_103_435 VGND VGND VPWR VPWR sky130_fd_sc_hd__decap_3
XFILLER_103_468 VGND VGND VPWR VPWR sky130_fd_sc_hd__decap_3
XFILLER_67_17 VGND VGND VPWR VPWR sky130_fd_sc_hd__decap_3
X_3469_ _3469_/A _3469_/B VGND VGND VPWR VPWR _4537_/C sky130_fd_sc_hd__nor2_2
XFILLER_69_360 VGND VGND VPWR VPWR sky130_fd_sc_hd__decap_3
XTAP_TAPCELL_ROW_4_301 VGND VPWR sky130_fd_sc_hd__tapvpwrvgnd_1
XFILLER_69_393 VGND VGND VPWR VPWR sky130_fd_sc_hd__decap_3
X_5139_ _4677_/B _5138_/X _5092_/C VGND VGND VPWR VPWR _5139_/X sky130_fd_sc_hd__o21a_2
XFILLER_17_408 VGND VGND VPWR VPWR sky130_fd_sc_hd__decap_3
XFILLER_17_419 VGND VGND VPWR VPWR sky130_fd_sc_hd__fill_2
XFILLER_57_588 VGND VGND VPWR VPWR sky130_fd_sc_hd__decap_3
XFILLER_72_514 VGND VGND VPWR VPWR sky130_fd_sc_hd__fill_1
XFILLER_84_341 VGND VGND VPWR VPWR sky130_fd_sc_hd__fill_1
XFILLER_84_352 VGND VGND VPWR VPWR sky130_fd_sc_hd__decap_3
XFILLER_25_452 VGND VGND VPWR VPWR sky130_fd_sc_hd__decap_3
XFILLER_44_249 VGND VGND VPWR VPWR sky130_fd_sc_hd__decap_3
XFILLER_13_603 VGND VGND VPWR VPWR sky130_fd_sc_hd__decap_3
XFILLER_52_260 VGND VGND VPWR VPWR sky130_fd_sc_hd__decap_3
XTAP_TAPCELL_ROW_80_1217 VGND VPWR sky130_fd_sc_hd__tapvpwrvgnd_1
XTAP_TAPCELL_ROW_80_1206 VGND VPWR sky130_fd_sc_hd__tapvpwrvgnd_1
XFILLER_13_647 VGND VGND VPWR VPWR sky130_fd_sc_hd__decap_3
XFILLER_52_282 VGND VGND VPWR VPWR sky130_fd_sc_hd__decap_3
XFILLER_40_466 VGND VGND VPWR VPWR sky130_fd_sc_hd__fill_1
XFILLER_40_477 VGND VGND VPWR VPWR sky130_fd_sc_hd__decap_3
XFILLER_9_629 VGND VGND VPWR VPWR sky130_fd_sc_hd__decap_3
XFILLER_4_312 VGND VGND VPWR VPWR sky130_fd_sc_hd__decap_3
XTAP_TAPCELL_ROW_10_369 VGND VPWR sky130_fd_sc_hd__tapvpwrvgnd_1
XTAP_TAPCELL_ROW_91_1346 VGND VPWR sky130_fd_sc_hd__tapvpwrvgnd_1
XFILLER_79_157 VGND VGND VPWR VPWR sky130_fd_sc_hd__decap_3
XFILLER_95_606 VGND VGND VPWR VPWR sky130_fd_sc_hd__decap_3
XFILLER_67_319 VGND VGND VPWR VPWR sky130_fd_sc_hd__decap_3
XFILLER_94_116 VGND VGND VPWR VPWR sky130_fd_sc_hd__fill_2
XFILLER_95_617 VGND VGND VPWR VPWR sky130_fd_sc_hd__decap_3
XFILLER_0_595 VGND VGND VPWR VPWR sky130_fd_sc_hd__decap_3
XFILLER_35_216 VGND VGND VPWR VPWR sky130_fd_sc_hd__fill_1
XFILLER_73_71 VGND VGND VPWR VPWR sky130_fd_sc_hd__decap_3
XFILLER_73_82 VGND VGND VPWR VPWR sky130_fd_sc_hd__decap_3
XFILLER_90_377 VGND VGND VPWR VPWR sky130_fd_sc_hd__decap_3
XTAP_TAPCELL_ROW_18_469 VGND VPWR sky130_fd_sc_hd__tapvpwrvgnd_1
XFILLER_31_433 VGND VGND VPWR VPWR sky130_fd_sc_hd__decap_3
XFILLER_71_591 VGND VGND VPWR VPWR sky130_fd_sc_hd__decap_3
XFILLER_31_455 VGND VGND VPWR VPWR sky130_fd_sc_hd__decap_3
XTAP_TAPCELL_ROW_100_1453 VGND VPWR sky130_fd_sc_hd__tapvpwrvgnd_1
XFILLER_31_488 VGND VGND VPWR VPWR sky130_fd_sc_hd__fill_1
XFILLER_8_640 VGND VGND VPWR VPWR sky130_fd_sc_hd__decap_3
XFILLER_8_651 VGND VGND VPWR VPWR sky130_fd_sc_hd__decap_3
X_4510_ _4510_/A0 _7292_/Q _4517_/S VGND VGND VPWR VPWR _7324_/D sky130_fd_sc_hd__mux2_2
XFILLER_8_684 VGND VGND VPWR VPWR sky130_fd_sc_hd__decap_3
X_4441_ _4813_/B _4441_/B VGND VGND VPWR VPWR _4827_/A sky130_fd_sc_hd__nand2_2
X_7160_ _7355_/CLK _7160_/D _6440_/Y VGND VGND VPWR VPWR _7160_/Q sky130_fd_sc_hd__dfrtp_2
XPHY_EDGE_ROW_9_Right_9 VGND VGND VPWR VPWR sky130_fd_sc_hd__decap_3
X_4372_ _4372_/A _4627_/A VGND VGND VPWR VPWR _5018_/A sky130_fd_sc_hd__or2_2
X_7091_ _7350_/CLK _7091_/D _6371_/Y VGND VGND VPWR VPWR _7091_/Q sky130_fd_sc_hd__dfrtp_2
X_3323_ _5129_/A _3519_/B _5294_/A _5129_/B VGND VGND VPWR VPWR _3323_/X sky130_fd_sc_hd__a31o_2
XFILLER_112_265 VGND VGND VPWR VPWR sky130_fd_sc_hd__decap_3
XFILLER_85_116 VGND VGND VPWR VPWR sky130_fd_sc_hd__decap_3
XFILLER_86_628 VGND VGND VPWR VPWR sky130_fd_sc_hd__decap_3
XTAP_TAPCELL_ROW_111_1582 VGND VPWR sky130_fd_sc_hd__tapvpwrvgnd_1
XPHY_EDGE_ROW_107_Right_107 VGND VGND VPWR VPWR sky130_fd_sc_hd__decap_3
XFILLER_98_477 VGND VGND VPWR VPWR sky130_fd_sc_hd__decap_3
XFILLER_39_555 VGND VGND VPWR VPWR sky130_fd_sc_hd__decap_3
XFILLER_66_352 VGND VGND VPWR VPWR sky130_fd_sc_hd__fill_2
XFILLER_94_672 VGND VGND VPWR VPWR sky130_fd_sc_hd__decap_3
XFILLER_39_588 VGND VGND VPWR VPWR sky130_fd_sc_hd__decap_3
XTAP_TAPCELL_ROW_37_701 VGND VPWR sky130_fd_sc_hd__tapvpwrvgnd_1
XFILLER_54_569 VGND VGND VPWR VPWR sky130_fd_sc_hd__decap_3
XFILLER_93_193 VGND VGND VPWR VPWR sky130_fd_sc_hd__decap_3
X_6944_ _6965_/CLK _6944_/D VGND VGND VPWR VPWR _6944_/Q sky130_fd_sc_hd__dfxtp_2
XFILLER_81_377 VGND VGND VPWR VPWR sky130_fd_sc_hd__decap_3
XFILLER_22_444 VGND VGND VPWR VPWR sky130_fd_sc_hd__fill_2
XFILLER_34_282 VGND VGND VPWR VPWR sky130_fd_sc_hd__decap_3
X_6875_ _6966_/CLK _6875_/D VGND VGND VPWR VPWR _6875_/Q sky130_fd_sc_hd__dfxtp_2
XFILLER_22_477 VGND VGND VPWR VPWR sky130_fd_sc_hd__decap_3
XFILLER_10_628 VGND VGND VPWR VPWR sky130_fd_sc_hd__decap_3
XFILLER_108_516 VGND VGND VPWR VPWR sky130_fd_sc_hd__decap_3
X_4708_ _7001_/Q _4825_/B VGND VGND VPWR VPWR _4826_/A sky130_fd_sc_hd__and2_2
X_5688_ _7350_/Q hold986/X _5699_/S VGND VGND VPWR VPWR _6694_/D sky130_fd_sc_hd__mux2_2
X_4639_ _4639_/A _4948_/B VGND VGND VPWR VPWR _4918_/A sky130_fd_sc_hd__or2_2
XFILLER_78_27 VGND VGND VPWR VPWR sky130_fd_sc_hd__fill_1
X_7358_ _7364_/CLK _7358_/D _6638_/Y VGND VGND VPWR VPWR _7358_/Q sky130_fd_sc_hd__dfrtp_2
Xhold640 _6742_/Q VGND VGND VPWR VPWR _6742_/D sky130_fd_sc_hd__dlygate4sd3_1
Xhold651 _6924_/Q VGND VGND VPWR VPWR _6924_/D sky130_fd_sc_hd__dlygate4sd3_1
Xhold662 _6859_/Q VGND VGND VPWR VPWR _6859_/D sky130_fd_sc_hd__dlygate4sd3_1
XFILLER_77_606 VGND VGND VPWR VPWR sky130_fd_sc_hd__decap_3
XFILLER_89_433 VGND VGND VPWR VPWR sky130_fd_sc_hd__decap_3
XFILLER_89_455 VGND VGND VPWR VPWR sky130_fd_sc_hd__fill_1
X_7289_ _7322_/CLK _7289_/D _6569_/Y VGND VGND VPWR VPWR _7289_/Q sky130_fd_sc_hd__dfrtp_2
Xhold673 _6891_/Q VGND VGND VPWR VPWR _6891_/D sky130_fd_sc_hd__dlygate4sd3_1
Xhold684 _6807_/Q VGND VGND VPWR VPWR _6807_/D sky130_fd_sc_hd__dlygate4sd3_1
Xhold695 _6919_/Q VGND VGND VPWR VPWR _6919_/D sky130_fd_sc_hd__dlygate4sd3_1
X_6309_ _6663_/A VGND VGND VPWR VPWR _6309_/Y sky130_fd_sc_hd__inv_2
XFILLER_77_617 VGND VGND VPWR VPWR sky130_fd_sc_hd__decap_3
XFILLER_103_287 VGND VGND VPWR VPWR sky130_fd_sc_hd__decap_3
XFILLER_76_149 VGND VGND VPWR VPWR sky130_fd_sc_hd__decap_3
XFILLER_94_15 VGND VGND VPWR VPWR sky130_fd_sc_hd__decap_3
XFILLER_57_363 VGND VGND VPWR VPWR sky130_fd_sc_hd__decap_3
XFILLER_69_190 VGND VGND VPWR VPWR sky130_fd_sc_hd__decap_3
XFILLER_85_650 VGND VGND VPWR VPWR sky130_fd_sc_hd__decap_3
XFILLER_17_205 VGND VGND VPWR VPWR sky130_fd_sc_hd__decap_3
XFILLER_84_160 VGND VGND VPWR VPWR sky130_fd_sc_hd__decap_3
XFILLER_91_119 VGND VGND VPWR VPWR sky130_fd_sc_hd__decap_3
XFILLER_45_558 VGND VGND VPWR VPWR sky130_fd_sc_hd__fill_2
XFILLER_72_333 VGND VGND VPWR VPWR sky130_fd_sc_hd__decap_3
XFILLER_84_193 VGND VGND VPWR VPWR sky130_fd_sc_hd__decap_3
XFILLER_25_260 VGND VGND VPWR VPWR sky130_fd_sc_hd__decap_3
XFILLER_53_591 VGND VGND VPWR VPWR sky130_fd_sc_hd__decap_3
XTAP_TAPCELL_ROW_15_428 VGND VPWR sky130_fd_sc_hd__tapvpwrvgnd_1
XFILLER_13_455 VGND VGND VPWR VPWR sky130_fd_sc_hd__decap_3
XFILLER_40_274 VGND VGND VPWR VPWR sky130_fd_sc_hd__decap_3
XFILLER_5_632 VGND VGND VPWR VPWR sky130_fd_sc_hd__decap_3
XFILLER_114_519 VGND VGND VPWR VPWR sky130_fd_sc_hd__decap_3
XFILLER_5_665 VGND VGND VPWR VPWR sky130_fd_sc_hd__decap_3
XFILLER_107_582 VGND VGND VPWR VPWR sky130_fd_sc_hd__decap_3
XFILLER_4_164 VGND VGND VPWR VPWR sky130_fd_sc_hd__decap_3
XFILLER_5_676 VGND VGND VPWR VPWR sky130_fd_sc_hd__decap_3
XFILLER_99_219 VGND VGND VPWR VPWR sky130_fd_sc_hd__decap_3
XFILLER_4_197 VGND VGND VPWR VPWR sky130_fd_sc_hd__fill_1
XFILLER_68_628 VGND VGND VPWR VPWR sky130_fd_sc_hd__decap_3
XFILLER_95_403 VGND VGND VPWR VPWR sky130_fd_sc_hd__decap_3
XFILLER_67_138 VGND VGND VPWR VPWR sky130_fd_sc_hd__fill_1
XFILLER_68_93 VGND VGND VPWR VPWR sky130_fd_sc_hd__decap_3
XFILLER_95_436 VGND VGND VPWR VPWR sky130_fd_sc_hd__decap_3
XFILLER_82_108 VGND VGND VPWR VPWR sky130_fd_sc_hd__decap_3
XFILLER_83_609 VGND VGND VPWR VPWR sky130_fd_sc_hd__decap_3
XFILLER_48_363 VGND VGND VPWR VPWR sky130_fd_sc_hd__fill_1
XFILLER_63_300 VGND VGND VPWR VPWR sky130_fd_sc_hd__decap_3
XFILLER_76_672 VGND VGND VPWR VPWR sky130_fd_sc_hd__decap_3
XFILLER_91_620 VGND VGND VPWR VPWR sky130_fd_sc_hd__decap_3
XFILLER_36_569 VGND VGND VPWR VPWR sky130_fd_sc_hd__decap_3
XFILLER_63_333 VGND VGND VPWR VPWR sky130_fd_sc_hd__decap_3
XFILLER_90_141 VGND VGND VPWR VPWR sky130_fd_sc_hd__decap_3
XFILLER_91_653 VGND VGND VPWR VPWR sky130_fd_sc_hd__decap_3
Xplace322 _3424_/S VGND VGND VPWR VPWR _4327_/A sky130_fd_sc_hd__buf_2
Xplace311 _3548_/X VGND VGND VPWR VPWR _4948_/A sky130_fd_sc_hd__buf_2
Xplace300 _3651_/Y VGND VGND VPWR VPWR _3922_/A2 sky130_fd_sc_hd__buf_2
XFILLER_63_366 VGND VGND VPWR VPWR sky130_fd_sc_hd__decap_3
XFILLER_90_174 VGND VGND VPWR VPWR sky130_fd_sc_hd__decap_3
Xplace355 _3417_/X VGND VGND VPWR VPWR _4335_/B1 sky130_fd_sc_hd__buf_2
Xplace344 _5425_/S VGND VGND VPWR VPWR _5383_/S sky130_fd_sc_hd__buf_2
Xplace333 _5708_/S VGND VGND VPWR VPWR _5703_/S sky130_fd_sc_hd__buf_2
X_4990_ _4620_/A _4989_/X _4374_/X VGND VGND VPWR VPWR _5004_/B sky130_fd_sc_hd__o21ai_2
XFILLER_16_271 VGND VGND VPWR VPWR sky130_fd_sc_hd__fill_2
Xplace377 _5151_/A VGND VGND VPWR VPWR _3833_/S sky130_fd_sc_hd__buf_2
Xplace388 _5190_/B VGND VGND VPWR VPWR _5177_/B sky130_fd_sc_hd__buf_2
Xplace366 _4265_/B VGND VGND VPWR VPWR _4102_/B sky130_fd_sc_hd__buf_2
X_3941_ _7369_/Q _4484_/A0 _3945_/S VGND VGND VPWR VPWR _7369_/D sky130_fd_sc_hd__mux2_2
XFILLER_31_252 VGND VGND VPWR VPWR sky130_fd_sc_hd__decap_3
XFILLER_90_3 VGND VGND VPWR VPWR sky130_fd_sc_hd__decap_3
Xplace399 _3383_/Y VGND VGND VPWR VPWR _4488_/S sky130_fd_sc_hd__buf_2
X_6660_ _6662_/A VGND VGND VPWR VPWR _6660_/Y sky130_fd_sc_hd__inv_2
X_3872_ _6921_/Q _3921_/A2 _3913_/B1 _6695_/Q _3871_/X VGND VGND VPWR VPWR _3872_/X
+ sky130_fd_sc_hd__a221o_2
XFILLER_31_274 VGND VGND VPWR VPWR sky130_fd_sc_hd__decap_3
X_6591_ _6625_/A VGND VGND VPWR VPWR _6591_/Y sky130_fd_sc_hd__inv_2
X_5611_ _5611_/A _5634_/B VGND VGND VPWR VPWR _7022_/D sky130_fd_sc_hd__and2_2
XFILLER_105_508 VGND VGND VPWR VPWR sky130_fd_sc_hd__decap_3
X_7212_ _7372_/CLK _7212_/D _6492_/Y VGND VGND VPWR VPWR _7212_/Q sky130_fd_sc_hd__dfrtp_2
X_4424_ _4425_/A _4425_/C _4649_/B VGND VGND VPWR VPWR _4446_/A sky130_fd_sc_hd__a21oi_2
XTAP_TAPCELL_ROW_113_1611 VGND VPWR sky130_fd_sc_hd__tapvpwrvgnd_1
XFILLER_113_541 VGND VGND VPWR VPWR sky130_fd_sc_hd__decap_3
X_7143_ _7307_/CLK _7143_/D _6423_/Y VGND VGND VPWR VPWR _7143_/Q sky130_fd_sc_hd__dfrtp_2
X_4355_ _4355_/A _4355_/B VGND VGND VPWR VPWR _4355_/X sky130_fd_sc_hd__or2_2
XPHY_EDGE_ROW_92_Left_209 VGND VGND VPWR VPWR sky130_fd_sc_hd__decap_3
XFILLER_59_606 VGND VGND VPWR VPWR sky130_fd_sc_hd__decap_3
XFILLER_59_617 VGND VGND VPWR VPWR sky130_fd_sc_hd__decap_3
X_7074_ _7395_/CLK _7074_/D _6354_/Y VGND VGND VPWR VPWR _7074_/Q sky130_fd_sc_hd__dfrtp_2
X_3306_ _6982_/Q _3328_/A _6981_/D _4696_/B _3340_/B VGND VGND VPWR VPWR _3378_/A
+ sky130_fd_sc_hd__o221a_2
XFILLER_113_585 VGND VGND VPWR VPWR sky130_fd_sc_hd__decap_3
XFILLER_58_127 VGND VGND VPWR VPWR sky130_fd_sc_hd__decap_3
X_4286_ _4286_/A _4286_/B VGND VGND VPWR VPWR _4288_/C sky130_fd_sc_hd__or2_2
XFILLER_39_352 VGND VGND VPWR VPWR sky130_fd_sc_hd__decap_3
XFILLER_67_650 VGND VGND VPWR VPWR sky130_fd_sc_hd__decap_3
XFILLER_86_469 VGND VGND VPWR VPWR sky130_fd_sc_hd__decap_3
XFILLER_27_547 VGND VGND VPWR VPWR sky130_fd_sc_hd__decap_3
XFILLER_54_333 VGND VGND VPWR VPWR sky130_fd_sc_hd__decap_3
XFILLER_64_29 VGND VGND VPWR VPWR sky130_fd_sc_hd__decap_3
XFILLER_81_130 VGND VGND VPWR VPWR sky130_fd_sc_hd__fill_1
XFILLER_82_631 VGND VGND VPWR VPWR sky130_fd_sc_hd__decap_3
XFILLER_81_152 VGND VGND VPWR VPWR sky130_fd_sc_hd__fill_1
XFILLER_82_675 VGND VGND VPWR VPWR sky130_fd_sc_hd__decap_3
XFILLER_35_591 VGND VGND VPWR VPWR sky130_fd_sc_hd__decap_3
XFILLER_81_196 VGND VGND VPWR VPWR sky130_fd_sc_hd__decap_3
X_6927_ _6966_/CLK _6927_/D VGND VGND VPWR VPWR _6927_/Q sky130_fd_sc_hd__dfxtp_2
Xfanout23 _6630_/A VGND VGND VPWR VPWR _6628_/A sky130_fd_sc_hd__buf_2
Xfanout34 _6624_/A VGND VGND VPWR VPWR _6633_/A sky130_fd_sc_hd__buf_2
Xfanout45 fanout46/X VGND VGND VPWR VPWR _6612_/A sky130_fd_sc_hd__clkdlybuf4s25_1
Xfanout56 _6653_/A VGND VGND VPWR VPWR _6652_/A sky130_fd_sc_hd__buf_2
X_6858_ _6978_/CLK _6858_/D VGND VGND VPWR VPWR _6858_/Q sky130_fd_sc_hd__dfxtp_2
XFILLER_10_414 VGND VGND VPWR VPWR sky130_fd_sc_hd__decap_3
XFILLER_13_11 VGND VGND VPWR VPWR sky130_fd_sc_hd__fill_1
XFILLER_50_572 VGND VGND VPWR VPWR sky130_fd_sc_hd__decap_3
Xfanout67 _6557_/A VGND VGND VPWR VPWR _6617_/A sky130_fd_sc_hd__buf_2
XTAP_TAPCELL_ROW_40_729 VGND VPWR sky130_fd_sc_hd__tapvpwrvgnd_1
XFILLER_10_469 VGND VGND VPWR VPWR sky130_fd_sc_hd__decap_3
X_6789_ clkload8/A _6789_/D VGND VGND VPWR VPWR _6789_/Q sky130_fd_sc_hd__dfxtp_2
XFILLER_6_429 VGND VGND VPWR VPWR sky130_fd_sc_hd__decap_3
XFILLER_108_368 VGND VGND VPWR VPWR sky130_fd_sc_hd__decap_3
XTAP_TAPCELL_ROW_20_497 VGND VPWR sky130_fd_sc_hd__tapvpwrvgnd_1
XTAP_TAPCELL_ROW_20_486 VGND VPWR sky130_fd_sc_hd__tapvpwrvgnd_1
XFILLER_2_613 VGND VGND VPWR VPWR sky130_fd_sc_hd__decap_3
XTAP_TAPCELL_ROW_75_1149 VGND VPWR sky130_fd_sc_hd__tapvpwrvgnd_1
XFILLER_2_657 VGND VGND VPWR VPWR sky130_fd_sc_hd__decap_3
XFILLER_104_563 VGND VGND VPWR VPWR sky130_fd_sc_hd__decap_3
XFILLER_1_145 VGND VGND VPWR VPWR sky130_fd_sc_hd__decap_3
XFILLER_77_447 VGND VGND VPWR VPWR sky130_fd_sc_hd__fill_1
XFILLER_38_52 VGND VGND VPWR VPWR sky130_fd_sc_hd__fill_2
XFILLER_65_609 VGND VGND VPWR VPWR sky130_fd_sc_hd__decap_3
XFILLER_92_406 VGND VGND VPWR VPWR sky130_fd_sc_hd__decap_3
XFILLER_38_74 VGND VGND VPWR VPWR sky130_fd_sc_hd__fill_1
XFILLER_38_85 VGND VGND VPWR VPWR sky130_fd_sc_hd__decap_3
XFILLER_58_672 VGND VGND VPWR VPWR sky130_fd_sc_hd__decap_3
XFILLER_73_620 VGND VGND VPWR VPWR sky130_fd_sc_hd__decap_3
Xhold1170 _7136_/Q VGND VGND VPWR VPWR _5394_/A0 sky130_fd_sc_hd__dlygate4sd3_1
XTAP_TAPCELL_ROW_48_829 VGND VPWR sky130_fd_sc_hd__tapvpwrvgnd_1
XFILLER_18_536 VGND VGND VPWR VPWR sky130_fd_sc_hd__decap_3
XFILLER_18_569 VGND VGND VPWR VPWR sky130_fd_sc_hd__decap_3
XFILLER_45_322 VGND VGND VPWR VPWR sky130_fd_sc_hd__decap_3
XFILLER_73_653 VGND VGND VPWR VPWR sky130_fd_sc_hd__decap_3
Xhold1181 _7128_/Q VGND VGND VPWR VPWR _5411_/A0 sky130_fd_sc_hd__dlygate4sd3_1
Xhold1192 _7162_/Q VGND VGND VPWR VPWR _5338_/A0 sky130_fd_sc_hd__dlygate4sd3_1
XFILLER_45_388 VGND VGND VPWR VPWR sky130_fd_sc_hd__decap_3
XFILLER_60_303 VGND VGND VPWR VPWR sky130_fd_sc_hd__decap_3
XFILLER_72_141 VGND VGND VPWR VPWR sky130_fd_sc_hd__decap_3
XFILLER_72_163 VGND VGND VPWR VPWR sky130_fd_sc_hd__decap_3
XTAP_TAPCELL_ROW_86_1289 VGND VPWR sky130_fd_sc_hd__tapvpwrvgnd_1
XTAP_TAPCELL_ROW_86_1278 VGND VPWR sky130_fd_sc_hd__tapvpwrvgnd_1
XFILLER_26_580 VGND VGND VPWR VPWR sky130_fd_sc_hd__decap_3
XTAP_TAPCELL_ROW_28_586 VGND VPWR sky130_fd_sc_hd__tapvpwrvgnd_1
XFILLER_13_252 VGND VGND VPWR VPWR sky130_fd_sc_hd__decap_3
XFILLER_41_561 VGND VGND VPWR VPWR sky130_fd_sc_hd__decap_3
XFILLER_41_594 VGND VGND VPWR VPWR sky130_fd_sc_hd__decap_3
XFILLER_9_201 VGND VGND VPWR VPWR sky130_fd_sc_hd__decap_3
XFILLER_9_245 VGND VGND VPWR VPWR sky130_fd_sc_hd__decap_3
Xclkload15 _7311_/CLK VGND VGND VPWR VPWR clkload15/X sky130_fd_sc_hd__clkbuf_8
Xclkload26 _7307_/CLK VGND VGND VPWR VPWR clkload26/Y sky130_fd_sc_hd__clkinv_2
XFILLER_55_6 VGND VGND VPWR VPWR sky130_fd_sc_hd__decap_3
XFILLER_5_462 VGND VGND VPWR VPWR sky130_fd_sc_hd__fill_1
XFILLER_107_390 VGND VGND VPWR VPWR sky130_fd_sc_hd__fill_2
XFILLER_79_92 VGND VGND VPWR VPWR sky130_fd_sc_hd__fill_1
X_4140_ _4117_/Y _4124_/B _4890_/B _4886_/A VGND VGND VPWR VPWR _4140_/X sky130_fd_sc_hd__a2bb2o_2
XFILLER_110_522 VGND VGND VPWR VPWR sky130_fd_sc_hd__decap_3
XFILLER_110_533 VGND VGND VPWR VPWR sky130_fd_sc_hd__decap_3
XFILLER_68_436 VGND VGND VPWR VPWR sky130_fd_sc_hd__decap_3
XFILLER_95_211 VGND VGND VPWR VPWR sky130_fd_sc_hd__decap_3
XFILLER_95_233 VGND VGND VPWR VPWR sky130_fd_sc_hd__decap_3
XFILLER_110_566 VGND VGND VPWR VPWR sky130_fd_sc_hd__decap_3
XFILLER_49_650 VGND VGND VPWR VPWR sky130_fd_sc_hd__decap_3
X_4071_ _7307_/Q _4488_/S _4437_/B1 _7371_/Q _4429_/C1 VGND VGND VPWR VPWR _4071_/X
+ sky130_fd_sc_hd__a221o_2
XFILLER_48_171 VGND VGND VPWR VPWR sky130_fd_sc_hd__decap_3
XFILLER_83_428 VGND VGND VPWR VPWR sky130_fd_sc_hd__decap_3
XFILLER_95_277 VGND VGND VPWR VPWR sky130_fd_sc_hd__decap_3
XFILLER_36_333 VGND VGND VPWR VPWR sky130_fd_sc_hd__decap_3
XFILLER_64_631 VGND VGND VPWR VPWR sky130_fd_sc_hd__decap_3
XFILLER_64_675 VGND VGND VPWR VPWR sky130_fd_sc_hd__decap_3
XFILLER_17_591 VGND VGND VPWR VPWR sky130_fd_sc_hd__decap_3
XFILLER_24_539 VGND VGND VPWR VPWR sky130_fd_sc_hd__decap_3
XFILLER_51_325 VGND VGND VPWR VPWR sky130_fd_sc_hd__decap_3
XFILLER_63_196 VGND VGND VPWR VPWR sky130_fd_sc_hd__fill_1
XFILLER_91_483 VGND VGND VPWR VPWR sky130_fd_sc_hd__decap_3
XFILLER_91_494 VGND VGND VPWR VPWR sky130_fd_sc_hd__decap_3
X_4973_ _5117_/A _4973_/B _3813_/Y VGND VGND VPWR VPWR _4973_/X sky130_fd_sc_hd__or3b_2
X_6712_ _7403_/CLK _6712_/D VGND VGND VPWR VPWR _6712_/Q sky130_fd_sc_hd__dfxtp_2
X_3924_ _3924_/A1 _5151_/A _3923_/X VGND VGND VPWR VPWR _7376_/D sky130_fd_sc_hd__o21a_2
XFILLER_32_561 VGND VGND VPWR VPWR sky130_fd_sc_hd__decap_3
X_6643_ _6643_/A VGND VGND VPWR VPWR _6643_/Y sky130_fd_sc_hd__inv_2
Xclkload9 clkload9/A VGND VGND VPWR VPWR clkload9/Y sky130_fd_sc_hd__clkinvlp_4
X_3855_ _3728_/Y _3847_/X _3849_/X _3714_/X _3854_/X VGND VGND VPWR VPWR _3855_/X
+ sky130_fd_sc_hd__a221o_2
X_6574_ _6608_/A VGND VGND VPWR VPWR _6574_/Y sky130_fd_sc_hd__inv_2
X_3786_ _6751_/Q _3892_/A2 _3890_/B1 _6733_/Q VGND VGND VPWR VPWR _3786_/X sky130_fd_sc_hd__a22o_2
Xoutput520 _6988_/Q VGND VGND VPWR VPWR pc_out[11] sky130_fd_sc_hd__clkdlybuf4s25_1
Xoutput542 _7008_/Q VGND VGND VPWR VPWR pc_out[31] sky130_fd_sc_hd__clkdlybuf4s25_1
Xoutput531 _6998_/Q VGND VGND VPWR VPWR pc_out[21] sky130_fd_sc_hd__clkdlybuf4s25_1
X_4407_ _7370_/Q _4394_/B _4436_/B1 _7178_/Q _4406_/X VGND VGND VPWR VPWR _4407_/X
+ sky130_fd_sc_hd__a221o_2
XFILLER_99_561 VGND VGND VPWR VPWR sky130_fd_sc_hd__decap_3
XFILLER_99_550 VGND VGND VPWR VPWR sky130_fd_sc_hd__decap_3
XFILLER_101_511 VGND VGND VPWR VPWR sky130_fd_sc_hd__decap_3
XFILLER_113_360 VGND VGND VPWR VPWR sky130_fd_sc_hd__decap_3
XFILLER_113_393 VGND VGND VPWR VPWR sky130_fd_sc_hd__decap_3
XFILLER_115_24 VGND VGND VPWR VPWR sky130_fd_sc_hd__decap_3
XFILLER_59_447 VGND VGND VPWR VPWR sky130_fd_sc_hd__fill_1
XFILLER_86_200 VGND VGND VPWR VPWR sky130_fd_sc_hd__decap_3
X_7126_ _7350_/CLK _7126_/D _6406_/Y VGND VGND VPWR VPWR _7126_/Q sky130_fd_sc_hd__dfrtp_2
X_4338_ _7319_/Q _3989_/S _4338_/B1 _7351_/Q _4248_/A VGND VGND VPWR VPWR _4338_/X
+ sky130_fd_sc_hd__a221o_2
XFILLER_99_594 VGND VGND VPWR VPWR sky130_fd_sc_hd__decap_3
XFILLER_101_544 VGND VGND VPWR VPWR sky130_fd_sc_hd__decap_3
XFILLER_115_57 VGND VGND VPWR VPWR sky130_fd_sc_hd__decap_3
XFILLER_47_609 VGND VGND VPWR VPWR sky130_fd_sc_hd__decap_3
XFILLER_59_458 VGND VGND VPWR VPWR sky130_fd_sc_hd__fill_1
X_7057_ _7349_/CLK _7057_/D _6337_/Y VGND VGND VPWR VPWR _7057_/Q sky130_fd_sc_hd__dfrtp_2
X_4269_ _7230_/Q _4414_/A2 _4269_/B1 _7043_/Q _4268_/X VGND VGND VPWR VPWR _4271_/C
+ sky130_fd_sc_hd__a221o_2
XFILLER_101_588 VGND VGND VPWR VPWR sky130_fd_sc_hd__decap_3
XFILLER_27_311 VGND VGND VPWR VPWR sky130_fd_sc_hd__decap_3
XFILLER_55_620 VGND VGND VPWR VPWR sky130_fd_sc_hd__decap_3
XFILLER_86_277 VGND VGND VPWR VPWR sky130_fd_sc_hd__decap_3
XFILLER_55_653 VGND VGND VPWR VPWR sky130_fd_sc_hd__decap_3
XFILLER_15_517 VGND VGND VPWR VPWR sky130_fd_sc_hd__decap_3
XFILLER_42_303 VGND VGND VPWR VPWR sky130_fd_sc_hd__decap_3
XFILLER_54_152 VGND VGND VPWR VPWR sky130_fd_sc_hd__decap_3
XFILLER_70_601 VGND VGND VPWR VPWR sky130_fd_sc_hd__decap_3
XFILLER_27_399 VGND VGND VPWR VPWR sky130_fd_sc_hd__fill_1
XFILLER_42_325 VGND VGND VPWR VPWR sky130_fd_sc_hd__decap_3
XFILLER_70_634 VGND VGND VPWR VPWR sky130_fd_sc_hd__decap_3
XFILLER_70_645 VGND VGND VPWR VPWR sky130_fd_sc_hd__decap_3
XFILLER_82_494 VGND VGND VPWR VPWR sky130_fd_sc_hd__fill_1
XFILLER_24_21 VGND VGND VPWR VPWR sky130_fd_sc_hd__decap_3
XFILLER_70_678 VGND VGND VPWR VPWR sky130_fd_sc_hd__decap_3
XTAP_TAPCELL_ROW_25_556 VGND VPWR sky130_fd_sc_hd__tapvpwrvgnd_1
XFILLER_23_561 VGND VGND VPWR VPWR sky130_fd_sc_hd__decap_3
XFILLER_24_65 VGND VGND VPWR VPWR sky130_fd_sc_hd__decap_3
XTAP_TAPCELL_ROW_53_887 VGND VPWR sky130_fd_sc_hd__tapvpwrvgnd_1
XFILLER_109_600 VGND VGND VPWR VPWR sky130_fd_sc_hd__decap_3
XFILLER_23_594 VGND VGND VPWR VPWR sky130_fd_sc_hd__decap_3
XFILLER_10_277 VGND VGND VPWR VPWR sky130_fd_sc_hd__decap_3
XFILLER_6_204 VGND VGND VPWR VPWR sky130_fd_sc_hd__fill_2
XFILLER_6_226 VGND VGND VPWR VPWR sky130_fd_sc_hd__fill_2
XFILLER_108_132 VGND VGND VPWR VPWR sky130_fd_sc_hd__decap_3
XFILLER_109_644 VGND VGND VPWR VPWR sky130_fd_sc_hd__decap_3
XFILLER_6_248 VGND VGND VPWR VPWR sky130_fd_sc_hd__decap_3
XFILLER_109_688 VGND VGND VPWR VPWR sky130_fd_sc_hd__decap_3
XFILLER_104_371 VGND VGND VPWR VPWR sky130_fd_sc_hd__decap_3
XFILLER_2_498 VGND VGND VPWR VPWR sky130_fd_sc_hd__decap_3
XFILLER_77_222 VGND VGND VPWR VPWR sky130_fd_sc_hd__fill_2
XFILLER_49_84 VGND VGND VPWR VPWR sky130_fd_sc_hd__fill_1
XFILLER_77_244 VGND VGND VPWR VPWR sky130_fd_sc_hd__decap_3
XFILLER_65_417 VGND VGND VPWR VPWR sky130_fd_sc_hd__fill_2
XFILLER_77_277 VGND VGND VPWR VPWR sky130_fd_sc_hd__decap_3
XTAP_TAPCELL_ROW_88_1307 VGND VPWR sky130_fd_sc_hd__tapvpwrvgnd_1
XFILLER_46_631 VGND VGND VPWR VPWR sky130_fd_sc_hd__decap_3
XFILLER_58_480 VGND VGND VPWR VPWR sky130_fd_sc_hd__decap_3
XFILLER_18_377 VGND VGND VPWR VPWR sky130_fd_sc_hd__decap_3
XFILLER_46_675 VGND VGND VPWR VPWR sky130_fd_sc_hd__decap_3
XFILLER_61_612 VGND VGND VPWR VPWR sky130_fd_sc_hd__decap_3
XFILLER_65_72 VGND VGND VPWR VPWR sky130_fd_sc_hd__fill_1
XFILLER_45_196 VGND VGND VPWR VPWR sky130_fd_sc_hd__decap_3
XFILLER_61_623 VGND VGND VPWR VPWR sky130_fd_sc_hd__decap_3
XFILLER_60_155 VGND VGND VPWR VPWR sky130_fd_sc_hd__decap_3
XFILLER_61_656 VGND VGND VPWR VPWR sky130_fd_sc_hd__decap_3
XFILLER_14_572 VGND VGND VPWR VPWR sky130_fd_sc_hd__decap_3
XTAP_TAPCELL_ROW_99_1436 VGND VPWR sky130_fd_sc_hd__tapvpwrvgnd_1
X_3640_ _3635_/X _3637_/X _3639_/X VGND VGND VPWR VPWR _3640_/X sky130_fd_sc_hd__o21ba_2
X_3571_ _3326_/A _3424_/S _5648_/B _3569_/X _3570_/X VGND VGND VPWR VPWR _3607_/B
+ sky130_fd_sc_hd__o32a_2
XFILLER_115_603 VGND VGND VPWR VPWR sky130_fd_sc_hd__decap_3
X_6290_ _6683_/A VGND VGND VPWR VPWR _6290_/Y sky130_fd_sc_hd__inv_2
X_5310_ _5310_/A0 _4836_/X _5315_/S VGND VGND VPWR VPWR _7175_/D sky130_fd_sc_hd__mux2_2
XFILLER_114_135 VGND VGND VPWR VPWR sky130_fd_sc_hd__fill_2
XFILLER_115_647 VGND VGND VPWR VPWR sky130_fd_sc_hd__decap_3
XFILLER_5_270 VGND VGND VPWR VPWR sky130_fd_sc_hd__fill_2
XFILLER_5_281 VGND VGND VPWR VPWR sky130_fd_sc_hd__decap_3
X_5241_ _5241_/A0 _4806_/X _5256_/S VGND VGND VPWR VPWR _7209_/D sky130_fd_sc_hd__mux2_2
XFILLER_68_200 VGND VGND VPWR VPWR sky130_fd_sc_hd__decap_3
XFILLER_29_609 VGND VGND VPWR VPWR sky130_fd_sc_hd__decap_3
XFILLER_68_233 VGND VGND VPWR VPWR sky130_fd_sc_hd__decap_3
XFILLER_96_542 VGND VGND VPWR VPWR sky130_fd_sc_hd__decap_3
X_4123_ _4119_/X _4122_/X _4327_/A VGND VGND VPWR VPWR _4124_/B sky130_fd_sc_hd__o21a_2
XFILLER_110_363 VGND VGND VPWR VPWR sky130_fd_sc_hd__fill_1
XFILLER_96_575 VGND VGND VPWR VPWR sky130_fd_sc_hd__decap_3
X_4054_ _4054_/A _4456_/A VGND VGND VPWR VPWR _4658_/A sky130_fd_sc_hd__nand2_2
XFILLER_37_620 VGND VGND VPWR VPWR sky130_fd_sc_hd__decap_3
XFILLER_83_225 VGND VGND VPWR VPWR sky130_fd_sc_hd__fill_1
XFILLER_36_141 VGND VGND VPWR VPWR sky130_fd_sc_hd__decap_3
XFILLER_37_653 VGND VGND VPWR VPWR sky130_fd_sc_hd__decap_3
XFILLER_52_601 VGND VGND VPWR VPWR sky130_fd_sc_hd__decap_3
XTAP_TAPCELL_ROW_108_1543 VGND VPWR sky130_fd_sc_hd__tapvpwrvgnd_1
XFILLER_101_15 VGND VGND VPWR VPWR sky130_fd_sc_hd__decap_3
XFILLER_52_634 VGND VGND VPWR VPWR sky130_fd_sc_hd__decap_3
XFILLER_52_645 VGND VGND VPWR VPWR sky130_fd_sc_hd__decap_3
XFILLER_24_347 VGND VGND VPWR VPWR sky130_fd_sc_hd__decap_3
XFILLER_52_678 VGND VGND VPWR VPWR sky130_fd_sc_hd__decap_3
X_4956_ _4948_/Y _4951_/Y _4954_/X _4955_/X VGND VGND VPWR VPWR _5662_/C sky130_fd_sc_hd__a211o_2
XTAP_TAPCELL_ROW_22_515 VGND VPWR sky130_fd_sc_hd__tapvpwrvgnd_1
XFILLER_20_531 VGND VGND VPWR VPWR sky130_fd_sc_hd__fill_1
XFILLER_20_542 VGND VGND VPWR VPWR sky130_fd_sc_hd__decap_3
X_4887_ _4886_/A _4890_/B _4814_/A VGND VGND VPWR VPWR _4887_/Y sky130_fd_sc_hd__a21oi_2
X_3907_ _6781_/Q _3922_/A2 _3922_/B1 _6869_/Q _3906_/X VGND VGND VPWR VPWR _3907_/X
+ sky130_fd_sc_hd__a221o_2
XTAP_TAPCELL_ROW_50_857 VGND VPWR sky130_fd_sc_hd__tapvpwrvgnd_1
XTAP_TAPCELL_ROW_50_846 VGND VPWR sky130_fd_sc_hd__tapvpwrvgnd_1
XFILLER_20_575 VGND VGND VPWR VPWR sky130_fd_sc_hd__decap_3
X_6626_ _6626_/A VGND VGND VPWR VPWR _6626_/Y sky130_fd_sc_hd__inv_2
X_3838_ _6773_/Q _3886_/A2 _3886_/B1 _6761_/Q _3837_/X VGND VGND VPWR VPWR _3838_/X
+ sky130_fd_sc_hd__a221o_2
X_6557_ _6557_/A VGND VGND VPWR VPWR _6557_/Y sky130_fd_sc_hd__inv_2
XFILLER_106_625 VGND VGND VPWR VPWR sky130_fd_sc_hd__decap_3
X_3769_ _3746_/C _3767_/X _3768_/X _3833_/S VGND VGND VPWR VPWR _4944_/B sky130_fd_sc_hd__o31a_2
XFILLER_105_113 VGND VGND VPWR VPWR sky130_fd_sc_hd__decap_3
XFILLER_10_23 VGND VGND VPWR VPWR sky130_fd_sc_hd__decap_3
X_6488_ _6654_/A VGND VGND VPWR VPWR _6488_/Y sky130_fd_sc_hd__inv_2
XFILLER_106_669 VGND VGND VPWR VPWR sky130_fd_sc_hd__decap_3
XTAP_TAPCELL_ROW_72_1119 VGND VPWR sky130_fd_sc_hd__tapvpwrvgnd_1
XFILLER_59_222 VGND VGND VPWR VPWR sky130_fd_sc_hd__fill_2
XFILLER_87_531 VGND VGND VPWR VPWR sky130_fd_sc_hd__decap_3
XFILLER_113_190 VGND VGND VPWR VPWR sky130_fd_sc_hd__decap_3
XFILLER_87_564 VGND VGND VPWR VPWR sky130_fd_sc_hd__decap_3
X_7109_ _7144_/CLK _7109_/D _6389_/Y VGND VGND VPWR VPWR _7109_/Q sky130_fd_sc_hd__dfrtp_2
XFILLER_101_352 VGND VGND VPWR VPWR sky130_fd_sc_hd__decap_3
XFILLER_101_374 VGND VGND VPWR VPWR sky130_fd_sc_hd__decap_3
XFILLER_19_119 VGND VGND VPWR VPWR sky130_fd_sc_hd__fill_1
XFILLER_74_203 VGND VGND VPWR VPWR sky130_fd_sc_hd__decap_3
XFILLER_87_597 VGND VGND VPWR VPWR sky130_fd_sc_hd__decap_3
XFILLER_19_98 VGND VGND VPWR VPWR sky130_fd_sc_hd__decap_3
XFILLER_28_631 VGND VGND VPWR VPWR sky130_fd_sc_hd__decap_3
XFILLER_59_299 VGND VGND VPWR VPWR sky130_fd_sc_hd__fill_2
XTAP_TAPCELL_ROW_58_946 VGND VPWR sky130_fd_sc_hd__tapvpwrvgnd_1
XFILLER_27_152 VGND VGND VPWR VPWR sky130_fd_sc_hd__decap_3
XFILLER_28_675 VGND VGND VPWR VPWR sky130_fd_sc_hd__decap_3
XFILLER_62_409 VGND VGND VPWR VPWR sky130_fd_sc_hd__fill_2
XTAP_TAPCELL_ROW_2_273 VGND VPWR sky130_fd_sc_hd__tapvpwrvgnd_1
XFILLER_15_303 VGND VGND VPWR VPWR sky130_fd_sc_hd__fill_2
XFILLER_43_612 VGND VGND VPWR VPWR sky130_fd_sc_hd__decap_3
XFILLER_43_623 VGND VGND VPWR VPWR sky130_fd_sc_hd__decap_3
XFILLER_43_656 VGND VGND VPWR VPWR sky130_fd_sc_hd__decap_3
XTAP_TAPCELL_ROW_83_1248 VGND VPWR sky130_fd_sc_hd__tapvpwrvgnd_1
XFILLER_70_475 VGND VGND VPWR VPWR sky130_fd_sc_hd__fill_1
XFILLER_23_380 VGND VGND VPWR VPWR sky130_fd_sc_hd__decap_3
XFILLER_11_553 VGND VGND VPWR VPWR sky130_fd_sc_hd__decap_3
XFILLER_11_564 VGND VGND VPWR VPWR sky130_fd_sc_hd__decap_3
XFILLER_51_63 VGND VGND VPWR VPWR sky130_fd_sc_hd__fill_2
XFILLER_109_441 VGND VGND VPWR VPWR sky130_fd_sc_hd__decap_3
XFILLER_11_597 VGND VGND VPWR VPWR sky130_fd_sc_hd__decap_3
XFILLER_51_96 VGND VGND VPWR VPWR sky130_fd_sc_hd__fill_1
XFILLER_7_535 VGND VGND VPWR VPWR sky130_fd_sc_hd__decap_3
XFILLER_109_452 VGND VGND VPWR VPWR sky130_fd_sc_hd__decap_3
XFILLER_7_579 VGND VGND VPWR VPWR sky130_fd_sc_hd__decap_3
XFILLER_109_485 VGND VGND VPWR VPWR sky130_fd_sc_hd__decap_3
XTAP_TAPCELL_ROW_94_1377 VGND VPWR sky130_fd_sc_hd__tapvpwrvgnd_1
XFILLER_112_628 VGND VGND VPWR VPWR sky130_fd_sc_hd__decap_3
XFILLER_2_251 VGND VGND VPWR VPWR sky130_fd_sc_hd__fill_1
XFILLER_104_190 VGND VGND VPWR VPWR sky130_fd_sc_hd__decap_3
XFILLER_78_531 VGND VGND VPWR VPWR sky130_fd_sc_hd__fill_1
XFILLER_78_542 VGND VGND VPWR VPWR sky130_fd_sc_hd__decap_3
XFILLER_38_406 VGND VGND VPWR VPWR sky130_fd_sc_hd__decap_3
XFILLER_78_575 VGND VGND VPWR VPWR sky130_fd_sc_hd__decap_3
XFILLER_93_523 VGND VGND VPWR VPWR sky130_fd_sc_hd__decap_3
XFILLER_18_6 VGND VGND VPWR VPWR sky130_fd_sc_hd__fill_1
XFILLER_19_620 VGND VGND VPWR VPWR sky130_fd_sc_hd__decap_3
XFILLER_38_439 VGND VGND VPWR VPWR sky130_fd_sc_hd__decap_3
XFILLER_65_225 VGND VGND VPWR VPWR sky130_fd_sc_hd__decap_3
XFILLER_65_247 VGND VGND VPWR VPWR sky130_fd_sc_hd__decap_3
XFILLER_76_82 VGND VGND VPWR VPWR sky130_fd_sc_hd__fill_2
XFILLER_93_556 VGND VGND VPWR VPWR sky130_fd_sc_hd__decap_3
XFILLER_18_141 VGND VGND VPWR VPWR sky130_fd_sc_hd__decap_3
XFILLER_19_653 VGND VGND VPWR VPWR sky130_fd_sc_hd__decap_3
XFILLER_34_601 VGND VGND VPWR VPWR sky130_fd_sc_hd__decap_3
XFILLER_53_409 VGND VGND VPWR VPWR sky130_fd_sc_hd__decap_3
XFILLER_93_567 VGND VGND VPWR VPWR sky130_fd_sc_hd__decap_3
XFILLER_18_185 VGND VGND VPWR VPWR sky130_fd_sc_hd__fill_1
XFILLER_34_634 VGND VGND VPWR VPWR sky130_fd_sc_hd__decap_3
XFILLER_46_472 VGND VGND VPWR VPWR sky130_fd_sc_hd__fill_1
XFILLER_80_239 VGND VGND VPWR VPWR sky130_fd_sc_hd__decap_3
XFILLER_34_645 VGND VGND VPWR VPWR sky130_fd_sc_hd__decap_3
XFILLER_34_678 VGND VGND VPWR VPWR sky130_fd_sc_hd__decap_3
XFILLER_92_70 VGND VGND VPWR VPWR sky130_fd_sc_hd__fill_2
XFILLER_92_81 VGND VGND VPWR VPWR sky130_fd_sc_hd__decap_3
X_4810_ _4813_/A _4810_/B _4829_/B VGND VGND VPWR VPWR _4810_/X sky130_fd_sc_hd__or3_2
XFILLER_21_306 VGND VGND VPWR VPWR sky130_fd_sc_hd__decap_3
X_4741_ _4761_/B _4761_/C _4762_/B VGND VGND VPWR VPWR _4741_/X sky130_fd_sc_hd__a21o_2
XTAP_TAPCELL_ROW_103_1484 VGND VPWR sky130_fd_sc_hd__tapvpwrvgnd_1
X_4672_ _6991_/Q _5633_/B VGND VGND VPWR VPWR _4673_/B sky130_fd_sc_hd__nor2_2
X_6411_ _6602_/A VGND VGND VPWR VPWR _6411_/Y sky130_fd_sc_hd__inv_2
X_7391_ _7392_/CLK _7391_/D _6671_/Y VGND VGND VPWR VPWR _7391_/Q sky130_fd_sc_hd__dfrtp_2
XFILLER_115_411 VGND VGND VPWR VPWR sky130_fd_sc_hd__decap_3
X_6342_ _6628_/A VGND VGND VPWR VPWR _6342_/Y sky130_fd_sc_hd__inv_2
X_3554_ _7317_/Q _4471_/S _4278_/B1 _7349_/Q VGND VGND VPWR VPWR _3556_/B sky130_fd_sc_hd__a22o_2
XFILLER_103_606 VGND VGND VPWR VPWR sky130_fd_sc_hd__decap_3
XFILLER_103_617 VGND VGND VPWR VPWR sky130_fd_sc_hd__decap_3
XFILLER_115_444 VGND VGND VPWR VPWR sky130_fd_sc_hd__decap_3
XFILLER_115_455 VGND VGND VPWR VPWR sky130_fd_sc_hd__decap_3
X_6273_ _6651_/A VGND VGND VPWR VPWR _6273_/Y sky130_fd_sc_hd__inv_2
X_3485_ _3502_/A _3502_/B _3485_/C VGND VGND VPWR VPWR _5144_/A sky130_fd_sc_hd__or3_4
XFILLER_102_127 VGND VGND VPWR VPWR sky130_fd_sc_hd__decap_3
XFILLER_115_488 VGND VGND VPWR VPWR sky130_fd_sc_hd__decap_3
XFILLER_88_317 VGND VGND VPWR VPWR sky130_fd_sc_hd__fill_2
XFILLER_102_149 VGND VGND VPWR VPWR sky130_fd_sc_hd__decap_3
XFILLER_111_650 VGND VGND VPWR VPWR sky130_fd_sc_hd__decap_3
XFILLER_69_564 VGND VGND VPWR VPWR sky130_fd_sc_hd__decap_3
XFILLER_69_597 VGND VGND VPWR VPWR sky130_fd_sc_hd__decap_3
X_5155_ _4467_/B _3923_/X _5151_/X _5154_/Y VGND VGND VPWR VPWR _5155_/X sky130_fd_sc_hd__a31o_2
XFILLER_56_214 VGND VGND VPWR VPWR sky130_fd_sc_hd__decap_3
XFILLER_56_236 VGND VGND VPWR VPWR sky130_fd_sc_hd__decap_3
XFILLER_84_545 VGND VGND VPWR VPWR sky130_fd_sc_hd__decap_3
X_5086_ _5086_/A _5101_/B _5100_/B VGND VGND VPWR VPWR _5086_/X sky130_fd_sc_hd__and3_2
X_4106_ _7141_/Q _4267_/A2 _4103_/X _4105_/X VGND VGND VPWR VPWR _4106_/X sky130_fd_sc_hd__a211o_2
XFILLER_84_578 VGND VGND VPWR VPWR sky130_fd_sc_hd__decap_3
XFILLER_84_589 VGND VGND VPWR VPWR sky130_fd_sc_hd__decap_3
X_4037_ _4394_/A _4394_/B _4036_/X VGND VGND VPWR VPWR _4458_/A sky130_fd_sc_hd__or3b_2
XTAP_TAPCELL_ROW_55_916 VGND VPWR sky130_fd_sc_hd__tapvpwrvgnd_1
XFILLER_112_47 VGND VGND VPWR VPWR sky130_fd_sc_hd__decap_3
XFILLER_25_612 VGND VGND VPWR VPWR sky130_fd_sc_hd__decap_3
XFILLER_25_623 VGND VGND VPWR VPWR sky130_fd_sc_hd__decap_3
XFILLER_37_483 VGND VGND VPWR VPWR sky130_fd_sc_hd__decap_3
XFILLER_64_280 VGND VGND VPWR VPWR sky130_fd_sc_hd__decap_3
XTAP_TAPCELL_ROW_69_1081 VGND VPWR sky130_fd_sc_hd__tapvpwrvgnd_1
XFILLER_24_122 VGND VGND VPWR VPWR sky130_fd_sc_hd__decap_3
XFILLER_24_133 VGND VGND VPWR VPWR sky130_fd_sc_hd__decap_3
XFILLER_25_656 VGND VGND VPWR VPWR sky130_fd_sc_hd__decap_3
XFILLER_52_442 VGND VGND VPWR VPWR sky130_fd_sc_hd__decap_3
XFILLER_72_18 VGND VGND VPWR VPWR sky130_fd_sc_hd__fill_2
XFILLER_72_29 VGND VGND VPWR VPWR sky130_fd_sc_hd__decap_3
XFILLER_40_604 VGND VGND VPWR VPWR sky130_fd_sc_hd__decap_3
XFILLER_52_486 VGND VGND VPWR VPWR sky130_fd_sc_hd__fill_1
XTAP_TAPCELL_ROW_35_673 VGND VPWR sky130_fd_sc_hd__tapvpwrvgnd_1
XFILLER_12_339 VGND VGND VPWR VPWR sky130_fd_sc_hd__decap_3
XFILLER_40_637 VGND VGND VPWR VPWR sky130_fd_sc_hd__decap_3
XFILLER_40_648 VGND VGND VPWR VPWR sky130_fd_sc_hd__decap_3
X_4939_ _4764_/B _4379_/B _4938_/Y _4937_/A _4852_/A VGND VGND VPWR VPWR _4939_/X
+ sky130_fd_sc_hd__o32a_2
XFILLER_21_11 VGND VGND VPWR VPWR sky130_fd_sc_hd__fill_1
X_6609_ _6610_/A VGND VGND VPWR VPWR _6609_/Y sky130_fd_sc_hd__inv_2
XFILLER_4_516 VGND VGND VPWR VPWR sky130_fd_sc_hd__decap_3
XFILLER_106_466 VGND VGND VPWR VPWR sky130_fd_sc_hd__decap_3
XFILLER_97_15 VGND VGND VPWR VPWR sky130_fd_sc_hd__fill_2
XFILLER_106_477 VGND VGND VPWR VPWR sky130_fd_sc_hd__decap_3
XFILLER_79_317 VGND VGND VPWR VPWR sky130_fd_sc_hd__decap_3
XTAP_TAPCELL_ROW_7_332 VGND VPWR sky130_fd_sc_hd__tapvpwrvgnd_1
XFILLER_102_672 VGND VGND VPWR VPWR sky130_fd_sc_hd__decap_3
XFILLER_94_309 VGND VGND VPWR VPWR sky130_fd_sc_hd__fill_1
XFILLER_47_225 VGND VGND VPWR VPWR sky130_fd_sc_hd__decap_3
XFILLER_47_236 VGND VGND VPWR VPWR sky130_fd_sc_hd__decap_3
XFILLER_47_269 VGND VGND VPWR VPWR sky130_fd_sc_hd__decap_3
XFILLER_62_206 VGND VGND VPWR VPWR sky130_fd_sc_hd__fill_2
XFILLER_75_556 VGND VGND VPWR VPWR sky130_fd_sc_hd__decap_3
XFILLER_75_567 VGND VGND VPWR VPWR sky130_fd_sc_hd__decap_3
XFILLER_16_601 VGND VGND VPWR VPWR sky130_fd_sc_hd__decap_3
XFILLER_16_634 VGND VGND VPWR VPWR sky130_fd_sc_hd__decap_3
XFILLER_28_461 VGND VGND VPWR VPWR sky130_fd_sc_hd__fill_2
XFILLER_46_85 VGND VGND VPWR VPWR sky130_fd_sc_hd__fill_1
XFILLER_90_548 VGND VGND VPWR VPWR sky130_fd_sc_hd__decap_3
XFILLER_16_645 VGND VGND VPWR VPWR sky130_fd_sc_hd__decap_3
XFILLER_16_678 VGND VGND VPWR VPWR sky130_fd_sc_hd__decap_3
XFILLER_31_615 VGND VGND VPWR VPWR sky130_fd_sc_hd__fill_1
XFILLER_31_626 VGND VGND VPWR VPWR sky130_fd_sc_hd__decap_3
XFILLER_70_250 VGND VGND VPWR VPWR sky130_fd_sc_hd__fill_2
XFILLER_70_272 VGND VGND VPWR VPWR sky130_fd_sc_hd__decap_3
XFILLER_31_659 VGND VGND VPWR VPWR sky130_fd_sc_hd__decap_3
XFILLER_30_169 VGND VGND VPWR VPWR sky130_fd_sc_hd__decap_3
XFILLER_11_372 VGND VGND VPWR VPWR sky130_fd_sc_hd__fill_2
XFILLER_7_13 VGND VGND VPWR VPWR sky130_fd_sc_hd__decap_3
XFILLER_7_321 VGND VGND VPWR VPWR sky130_fd_sc_hd__decap_3
XTAP_TAPCELL_ROW_96_1406 VGND VPWR sky130_fd_sc_hd__tapvpwrvgnd_1
XFILLER_7_343 VGND VGND VPWR VPWR sky130_fd_sc_hd__decap_3
XFILLER_7_354 VGND VGND VPWR VPWR sky130_fd_sc_hd__decap_3
XFILLER_7_57 VGND VGND VPWR VPWR sky130_fd_sc_hd__fill_1
XFILLER_109_260 VGND VGND VPWR VPWR sky130_fd_sc_hd__fill_2
XFILLER_98_604 VGND VGND VPWR VPWR sky130_fd_sc_hd__decap_3
XFILLER_112_403 VGND VGND VPWR VPWR sky130_fd_sc_hd__decap_3
XFILLER_3_582 VGND VGND VPWR VPWR sky130_fd_sc_hd__decap_3
XFILLER_98_648 VGND VGND VPWR VPWR sky130_fd_sc_hd__decap_3
XFILLER_98_637 VGND VGND VPWR VPWR sky130_fd_sc_hd__decap_3
XFILLER_112_436 VGND VGND VPWR VPWR sky130_fd_sc_hd__decap_3
XFILLER_97_147 VGND VGND VPWR VPWR sky130_fd_sc_hd__decap_3
XFILLER_112_469 VGND VGND VPWR VPWR sky130_fd_sc_hd__decap_3
XFILLER_97_169 VGND VGND VPWR VPWR sky130_fd_sc_hd__fill_1
XFILLER_66_578 VGND VGND VPWR VPWR sky130_fd_sc_hd__decap_3
XFILLER_66_589 VGND VGND VPWR VPWR sky130_fd_sc_hd__decap_3
X_6960_ _6968_/CLK _6960_/D VGND VGND VPWR VPWR _6960_/Q sky130_fd_sc_hd__dfxtp_2
XFILLER_81_548 VGND VGND VPWR VPWR sky130_fd_sc_hd__decap_3
XTAP_TAPCELL_ROW_105_1513 VGND VPWR sky130_fd_sc_hd__tapvpwrvgnd_1
XFILLER_19_494 VGND VGND VPWR VPWR sky130_fd_sc_hd__fill_2
X_6891_ _6941_/CLK _6891_/D VGND VGND VPWR VPWR _6891_/Q sky130_fd_sc_hd__dfxtp_2
XFILLER_22_604 VGND VGND VPWR VPWR sky130_fd_sc_hd__decap_3
XFILLER_34_475 VGND VGND VPWR VPWR sky130_fd_sc_hd__fill_1
XFILLER_34_486 VGND VGND VPWR VPWR sky130_fd_sc_hd__decap_3
XFILLER_22_637 VGND VGND VPWR VPWR sky130_fd_sc_hd__decap_3
XFILLER_22_648 VGND VGND VPWR VPWR sky130_fd_sc_hd__decap_3
XTAP_TAPCELL_ROW_32_632 VGND VPWR sky130_fd_sc_hd__tapvpwrvgnd_1
X_4724_ _4720_/A _4655_/X _4658_/B VGND VGND VPWR VPWR _4724_/X sky130_fd_sc_hd__o21a_2
XTAP_TAPCELL_ROW_60_974 VGND VPWR sky130_fd_sc_hd__tapvpwrvgnd_1
XFILLER_30_681 VGND VGND VPWR VPWR sky130_fd_sc_hd__decap_3
X_4655_ _4610_/A _4765_/B _4611_/Y _4762_/A _4744_/B VGND VGND VPWR VPWR _4655_/X
+ sky130_fd_sc_hd__a221o_2
X_7374_ _7374_/CLK _7374_/D _6654_/Y VGND VGND VPWR VPWR _7374_/Q sky130_fd_sc_hd__dfrtp_2
Xhold800 _6819_/Q VGND VGND VPWR VPWR _6819_/D sky130_fd_sc_hd__dlygate4sd3_1
Xhold811 _6871_/Q VGND VGND VPWR VPWR _6871_/D sky130_fd_sc_hd__dlygate4sd3_1
X_3606_ _4614_/B _3603_/B _3605_/Y VGND VGND VPWR VPWR _3606_/X sky130_fd_sc_hd__o21a_2
XTAP_TAPCELL_ROW_116_1642 VGND VPWR sky130_fd_sc_hd__tapvpwrvgnd_1
XFILLER_115_230 VGND VGND VPWR VPWR sky130_fd_sc_hd__decap_3
XFILLER_1_508 VGND VGND VPWR VPWR sky130_fd_sc_hd__decap_3
Xhold822 _6903_/Q VGND VGND VPWR VPWR _6903_/D sky130_fd_sc_hd__dlygate4sd3_1
Xhold833 _6722_/Q VGND VGND VPWR VPWR _6722_/D sky130_fd_sc_hd__dlygate4sd3_1
Xhold844 _7058_/Q VGND VGND VPWR VPWR _7058_/D sky130_fd_sc_hd__dlygate4sd3_1
Xhold855 _7082_/Q VGND VGND VPWR VPWR _7082_/D sky130_fd_sc_hd__dlygate4sd3_1
Xmax_cap563 _6558_/A VGND VGND VPWR VPWR _6494_/A sky130_fd_sc_hd__buf_4
Xmax_cap552 _4745_/A VGND VGND VPWR VPWR _4610_/A sky130_fd_sc_hd__clkbuf_2
X_6325_ _6637_/A VGND VGND VPWR VPWR _6325_/Y sky130_fd_sc_hd__inv_2
X_3537_ _3427_/B _3521_/Y _5057_/A _3527_/A _3536_/Y VGND VGND VPWR VPWR _3537_/X
+ sky130_fd_sc_hd__o221a_2
XTAP_TAPCELL_ROW_116_1653 VGND VPWR sky130_fd_sc_hd__tapvpwrvgnd_1
XFILLER_107_36 VGND VGND VPWR VPWR sky130_fd_sc_hd__decap_3
XFILLER_89_615 VGND VGND VPWR VPWR sky130_fd_sc_hd__fill_1
XFILLER_89_626 VGND VGND VPWR VPWR sky130_fd_sc_hd__decap_3
Xhold866 _7092_/Q VGND VGND VPWR VPWR _7092_/D sky130_fd_sc_hd__dlygate4sd3_1
Xhold877 _7064_/Q VGND VGND VPWR VPWR _7064_/D sky130_fd_sc_hd__dlygate4sd3_1
Xhold888 _7083_/Q VGND VGND VPWR VPWR _7083_/D sky130_fd_sc_hd__dlygate4sd3_1
Xmax_cap574 _6567_/A VGND VGND VPWR VPWR _6571_/A sky130_fd_sc_hd__buf_2
XFILLER_67_29 VGND VGND VPWR VPWR sky130_fd_sc_hd__decap_3
XFILLER_88_136 VGND VGND VPWR VPWR sky130_fd_sc_hd__decap_3
XFILLER_89_659 VGND VGND VPWR VPWR sky130_fd_sc_hd__decap_3
Xhold899 _7110_/Q VGND VGND VPWR VPWR _7110_/D sky130_fd_sc_hd__dlygate4sd3_1
X_3468_ _7281_/Q _5157_/S _4335_/B1 _7089_/Q _3467_/X VGND VGND VPWR VPWR _3468_/X
+ sky130_fd_sc_hd__a221o_2
XFILLER_76_309 VGND VGND VPWR VPWR sky130_fd_sc_hd__fill_1
X_5207_ _5207_/A _5209_/B VGND VGND VPWR VPWR _7225_/D sky130_fd_sc_hd__and2_2
X_3399_ _3399_/A _3399_/B VGND VGND VPWR VPWR _3449_/B sky130_fd_sc_hd__nor2_4
XTAP_TAPCELL_ROW_4_302 VGND VPWR sky130_fd_sc_hd__tapvpwrvgnd_1
XFILLER_111_491 VGND VGND VPWR VPWR sky130_fd_sc_hd__decap_3
XFILLER_29_225 VGND VGND VPWR VPWR sky130_fd_sc_hd__decap_3
X_5138_ _3665_/B _3914_/X _5151_/A VGND VGND VPWR VPWR _5138_/X sky130_fd_sc_hd__mux2_2
XFILLER_29_258 VGND VGND VPWR VPWR sky130_fd_sc_hd__decap_3
XFILLER_57_567 VGND VGND VPWR VPWR sky130_fd_sc_hd__decap_3
XFILLER_16_11 VGND VGND VPWR VPWR sky130_fd_sc_hd__fill_1
XFILLER_44_228 VGND VGND VPWR VPWR sky130_fd_sc_hd__decap_3
XFILLER_83_28 VGND VGND VPWR VPWR sky130_fd_sc_hd__decap_3
X_5069_ _6987_/Q _5069_/B VGND VGND VPWR VPWR _5069_/X sky130_fd_sc_hd__or2_2
XFILLER_72_559 VGND VGND VPWR VPWR sky130_fd_sc_hd__decap_3
XFILLER_13_615 VGND VGND VPWR VPWR sky130_fd_sc_hd__fill_1
XFILLER_13_626 VGND VGND VPWR VPWR sky130_fd_sc_hd__decap_3
XFILLER_16_77 VGND VGND VPWR VPWR sky130_fd_sc_hd__decap_3
XFILLER_40_401 VGND VGND VPWR VPWR sky130_fd_sc_hd__decap_3
XFILLER_52_250 VGND VGND VPWR VPWR sky130_fd_sc_hd__fill_2
XTAP_TAPCELL_ROW_80_1207 VGND VPWR sky130_fd_sc_hd__tapvpwrvgnd_1
XFILLER_13_659 VGND VGND VPWR VPWR sky130_fd_sc_hd__decap_3
XFILLER_16_88 VGND VGND VPWR VPWR sky130_fd_sc_hd__decap_3
XFILLER_52_272 VGND VGND VPWR VPWR sky130_fd_sc_hd__decap_3
XFILLER_52_294 VGND VGND VPWR VPWR sky130_fd_sc_hd__decap_3
XFILLER_80_581 VGND VGND VPWR VPWR sky130_fd_sc_hd__decap_3
XFILLER_80_592 VGND VGND VPWR VPWR sky130_fd_sc_hd__decap_3
XFILLER_12_147 VGND VGND VPWR VPWR sky130_fd_sc_hd__fill_1
XFILLER_40_489 VGND VGND VPWR VPWR sky130_fd_sc_hd__decap_3
XPHY_EDGE_ROW_112_Left_229 VGND VGND VPWR VPWR sky130_fd_sc_hd__decap_3
XFILLER_4_346 VGND VGND VPWR VPWR sky130_fd_sc_hd__fill_2
XFILLER_79_103 VGND VGND VPWR VPWR sky130_fd_sc_hd__decap_3
XTAP_TAPCELL_ROW_91_1347 VGND VPWR sky130_fd_sc_hd__tapvpwrvgnd_1
XFILLER_0_530 VGND VGND VPWR VPWR sky130_fd_sc_hd__fill_2
XFILLER_79_125 VGND VGND VPWR VPWR sky130_fd_sc_hd__decap_3
XFILLER_0_552 VGND VGND VPWR VPWR sky130_fd_sc_hd__decap_3
XFILLER_79_169 VGND VGND VPWR VPWR sky130_fd_sc_hd__decap_3
XFILLER_95_629 VGND VGND VPWR VPWR sky130_fd_sc_hd__decap_3
XFILLER_102_480 VGND VGND VPWR VPWR sky130_fd_sc_hd__decap_3
XFILLER_75_320 VGND VGND VPWR VPWR sky130_fd_sc_hd__decap_3
XFILLER_88_681 VGND VGND VPWR VPWR sky130_fd_sc_hd__decap_3
XFILLER_48_567 VGND VGND VPWR VPWR sky130_fd_sc_hd__decap_3
XFILLER_48_589 VGND VGND VPWR VPWR sky130_fd_sc_hd__decap_3
XFILLER_90_323 VGND VGND VPWR VPWR sky130_fd_sc_hd__decap_3
XFILLER_113_90 VGND VGND VPWR VPWR sky130_fd_sc_hd__decap_3
XFILLER_63_548 VGND VGND VPWR VPWR sky130_fd_sc_hd__decap_3
XFILLER_16_475 VGND VGND VPWR VPWR sky130_fd_sc_hd__fill_1
XFILLER_71_570 VGND VGND VPWR VPWR sky130_fd_sc_hd__decap_3
XFILLER_90_389 VGND VGND VPWR VPWR sky130_fd_sc_hd__decap_3
XFILLER_43_272 VGND VGND VPWR VPWR sky130_fd_sc_hd__decap_3
XFILLER_31_467 VGND VGND VPWR VPWR sky130_fd_sc_hd__fill_1
XFILLER_12_681 VGND VGND VPWR VPWR sky130_fd_sc_hd__decap_3
XTAP_TAPCELL_ROW_100_1454 VGND VPWR sky130_fd_sc_hd__tapvpwrvgnd_1
XFILLER_11_191 VGND VGND VPWR VPWR sky130_fd_sc_hd__decap_3
XFILLER_8_663 VGND VGND VPWR VPWR sky130_fd_sc_hd__decap_3
XFILLER_7_151 VGND VGND VPWR VPWR sky130_fd_sc_hd__decap_3
X_4440_ _4440_/A _4650_/B VGND VGND VPWR VPWR _4441_/B sky130_fd_sc_hd__nand2_2
X_4371_ _4371_/A _4371_/B VGND VGND VPWR VPWR _4371_/Y sky130_fd_sc_hd__nand2_2
XFILLER_98_401 VGND VGND VPWR VPWR sky130_fd_sc_hd__decap_3
XFILLER_112_211 VGND VGND VPWR VPWR sky130_fd_sc_hd__fill_2
XFILLER_112_233 VGND VGND VPWR VPWR sky130_fd_sc_hd__decap_3
X_7090_ _7355_/CLK _7090_/D _6370_/Y VGND VGND VPWR VPWR _7090_/Q sky130_fd_sc_hd__dfrtp_2
XFILLER_112_277 VGND VGND VPWR VPWR sky130_fd_sc_hd__decap_3
XFILLER_58_309 VGND VGND VPWR VPWR sky130_fd_sc_hd__decap_3
XFILLER_85_106 VGND VGND VPWR VPWR sky130_fd_sc_hd__decap_3
XFILLER_86_607 VGND VGND VPWR VPWR sky130_fd_sc_hd__decap_3
XFILLER_98_489 VGND VGND VPWR VPWR sky130_fd_sc_hd__decap_3
XFILLER_78_180 VGND VGND VPWR VPWR sky130_fd_sc_hd__decap_3
XTAP_TAPCELL_ROW_111_1583 VGND VPWR sky130_fd_sc_hd__tapvpwrvgnd_1
XFILLER_39_567 VGND VGND VPWR VPWR sky130_fd_sc_hd__decap_3
XFILLER_94_640 VGND VGND VPWR VPWR sky130_fd_sc_hd__decap_3
XFILLER_94_651 VGND VGND VPWR VPWR sky130_fd_sc_hd__decap_3
XFILLER_93_172 VGND VGND VPWR VPWR sky130_fd_sc_hd__fill_2
XFILLER_94_684 VGND VGND VPWR VPWR sky130_fd_sc_hd__decap_3
XFILLER_26_239 VGND VGND VPWR VPWR sky130_fd_sc_hd__decap_3
X_6943_ _6943_/CLK _6943_/D VGND VGND VPWR VPWR _6943_/Q sky130_fd_sc_hd__dfxtp_2
XFILLER_34_261 VGND VGND VPWR VPWR sky130_fd_sc_hd__decap_3
X_6874_ _7378_/CLK _6874_/D VGND VGND VPWR VPWR _6874_/Q sky130_fd_sc_hd__dfxtp_2
XTAP_TAPCELL_ROW_66_1040 VGND VPWR sky130_fd_sc_hd__tapvpwrvgnd_1
XFILLER_34_294 VGND VGND VPWR VPWR sky130_fd_sc_hd__decap_3
XFILLER_62_581 VGND VGND VPWR VPWR sky130_fd_sc_hd__decap_3
XFILLER_62_592 VGND VGND VPWR VPWR sky130_fd_sc_hd__decap_3
XTAP_TAPCELL_ROW_45_790 VGND VPWR sky130_fd_sc_hd__tapvpwrvgnd_1
XFILLER_10_607 VGND VGND VPWR VPWR sky130_fd_sc_hd__decap_3
XFILLER_22_467 VGND VGND VPWR VPWR sky130_fd_sc_hd__decap_3
X_4707_ _6998_/Q _6999_/Q _7000_/Q _4912_/A VGND VGND VPWR VPWR _4825_/B sky130_fd_sc_hd__and4_2
XFILLER_108_528 VGND VGND VPWR VPWR sky130_fd_sc_hd__decap_3
XFILLER_108_539 VGND VGND VPWR VPWR sky130_fd_sc_hd__decap_3
X_4638_ _4950_/A _4950_/B VGND VGND VPWR VPWR _4948_/B sky130_fd_sc_hd__and2_2
Xhold630 _6723_/Q VGND VGND VPWR VPWR _6723_/D sky130_fd_sc_hd__dlygate4sd3_1
XFILLER_116_572 VGND VGND VPWR VPWR sky130_fd_sc_hd__decap_3
XFILLER_1_305 VGND VGND VPWR VPWR sky130_fd_sc_hd__fill_1
X_7357_ _7392_/CLK _7357_/D _6637_/Y VGND VGND VPWR VPWR _7357_/Q sky130_fd_sc_hd__dfrtp_2
Xhold641 _6732_/Q VGND VGND VPWR VPWR _6732_/D sky130_fd_sc_hd__dlygate4sd3_1
Xhold652 _6822_/Q VGND VGND VPWR VPWR _6822_/D sky130_fd_sc_hd__dlygate4sd3_1
Xhold663 _6834_/Q VGND VGND VPWR VPWR _6834_/D sky130_fd_sc_hd__dlygate4sd3_1
X_4569_ _4569_/A _4577_/B VGND VGND VPWR VPWR _7296_/D sky130_fd_sc_hd__and2_2
XTAP_TAPCELL_ROW_77_1180 VGND VPWR sky130_fd_sc_hd__tapvpwrvgnd_1
XFILLER_103_211 VGND VGND VPWR VPWR sky130_fd_sc_hd__fill_1
XFILLER_103_222 VGND VGND VPWR VPWR sky130_fd_sc_hd__fill_2
XFILLER_89_445 VGND VGND VPWR VPWR sky130_fd_sc_hd__decap_3
X_7288_ _7355_/CLK _7288_/D _6568_/Y VGND VGND VPWR VPWR _7288_/Q sky130_fd_sc_hd__dfrtp_2
Xhold674 _6795_/Q VGND VGND VPWR VPWR _6795_/D sky130_fd_sc_hd__dlygate4sd3_1
Xhold685 _6937_/Q VGND VGND VPWR VPWR _6937_/D sky130_fd_sc_hd__dlygate4sd3_1
Xhold696 _6840_/Q VGND VGND VPWR VPWR _6840_/D sky130_fd_sc_hd__dlygate4sd3_1
X_6308_ _6663_/A VGND VGND VPWR VPWR _6308_/Y sky130_fd_sc_hd__inv_2
XFILLER_103_244 VGND VGND VPWR VPWR sky130_fd_sc_hd__fill_1
XFILLER_77_629 VGND VGND VPWR VPWR sky130_fd_sc_hd__decap_3
XFILLER_103_299 VGND VGND VPWR VPWR sky130_fd_sc_hd__decap_3
XFILLER_94_27 VGND VGND VPWR VPWR sky130_fd_sc_hd__fill_1
XFILLER_57_331 VGND VGND VPWR VPWR sky130_fd_sc_hd__decap_3
XFILLER_85_662 VGND VGND VPWR VPWR sky130_fd_sc_hd__decap_3
XFILLER_17_217 VGND VGND VPWR VPWR sky130_fd_sc_hd__fill_2
XFILLER_17_228 VGND VGND VPWR VPWR sky130_fd_sc_hd__fill_2
XFILLER_85_673 VGND VGND VPWR VPWR sky130_fd_sc_hd__decap_3
XFILLER_72_356 VGND VGND VPWR VPWR sky130_fd_sc_hd__fill_1
XFILLER_27_98 VGND VGND VPWR VPWR sky130_fd_sc_hd__decap_3
XFILLER_13_423 VGND VGND VPWR VPWR sky130_fd_sc_hd__decap_3
XFILLER_43_20 VGND VGND VPWR VPWR sky130_fd_sc_hd__decap_3
XFILLER_53_570 VGND VGND VPWR VPWR sky130_fd_sc_hd__decap_3
XTAP_TAPCELL_ROW_15_429 VGND VPWR sky130_fd_sc_hd__tapvpwrvgnd_1
XFILLER_40_231 VGND VGND VPWR VPWR sky130_fd_sc_hd__decap_3
XFILLER_40_253 VGND VGND VPWR VPWR sky130_fd_sc_hd__decap_3
XFILLER_9_405 VGND VGND VPWR VPWR sky130_fd_sc_hd__fill_1
XFILLER_43_75 VGND VGND VPWR VPWR sky130_fd_sc_hd__decap_3
XFILLER_9_449 VGND VGND VPWR VPWR sky130_fd_sc_hd__decap_3
XFILLER_9_438 VGND VGND VPWR VPWR sky130_fd_sc_hd__fill_1
XFILLER_5_600 VGND VGND VPWR VPWR sky130_fd_sc_hd__decap_3
XFILLER_5_644 VGND VGND VPWR VPWR sky130_fd_sc_hd__decap_3
XFILLER_107_550 VGND VGND VPWR VPWR sky130_fd_sc_hd__decap_3
XFILLER_107_561 VGND VGND VPWR VPWR sky130_fd_sc_hd__decap_3
XFILLER_4_14 VGND VGND VPWR VPWR sky130_fd_sc_hd__decap_3
XFILLER_4_176 VGND VGND VPWR VPWR sky130_fd_sc_hd__decap_3
XFILLER_5_688 VGND VGND VPWR VPWR sky130_fd_sc_hd__decap_3
XFILLER_107_594 VGND VGND VPWR VPWR sky130_fd_sc_hd__decap_3
XFILLER_68_607 VGND VGND VPWR VPWR sky130_fd_sc_hd__decap_3
XFILLER_76_640 VGND VGND VPWR VPWR sky130_fd_sc_hd__decap_3
XFILLER_76_651 VGND VGND VPWR VPWR sky130_fd_sc_hd__decap_3
XFILLER_48_386 VGND VGND VPWR VPWR sky130_fd_sc_hd__decap_3
XFILLER_63_312 VGND VGND VPWR VPWR sky130_fd_sc_hd__decap_3
XFILLER_75_161 VGND VGND VPWR VPWR sky130_fd_sc_hd__decap_3
XFILLER_75_172 VGND VGND VPWR VPWR sky130_fd_sc_hd__decap_3
XFILLER_76_684 VGND VGND VPWR VPWR sky130_fd_sc_hd__decap_3
XFILLER_91_632 VGND VGND VPWR VPWR sky130_fd_sc_hd__decap_3
Xplace312 _3534_/Y VGND VGND VPWR VPWR _5071_/A sky130_fd_sc_hd__buf_2
Xplace301 _3879_/B1 VGND VGND VPWR VPWR _3889_/A2 sky130_fd_sc_hd__buf_2
XFILLER_16_250 VGND VGND VPWR VPWR sky130_fd_sc_hd__fill_2
XFILLER_23_209 VGND VGND VPWR VPWR sky130_fd_sc_hd__fill_1
XFILLER_63_389 VGND VGND VPWR VPWR sky130_fd_sc_hd__decap_3
XFILLER_91_665 VGND VGND VPWR VPWR sky130_fd_sc_hd__decap_3
XFILLER_91_676 VGND VGND VPWR VPWR sky130_fd_sc_hd__decap_3
Xplace345 _4606_/Y VGND VGND VPWR VPWR _5092_/C sky130_fd_sc_hd__buf_2
Xplace334 _5699_/S VGND VGND VPWR VPWR _5708_/S sky130_fd_sc_hd__buf_2
Xplace323 _4401_/A2 VGND VGND VPWR VPWR _4437_/A2 sky130_fd_sc_hd__buf_2
XFILLER_44_581 VGND VGND VPWR VPWR sky130_fd_sc_hd__decap_3
XFILLER_44_592 VGND VGND VPWR VPWR sky130_fd_sc_hd__decap_3
XFILLER_90_186 VGND VGND VPWR VPWR sky130_fd_sc_hd__fill_1
XFILLER_90_197 VGND VGND VPWR VPWR sky130_fd_sc_hd__decap_3
Xplace378 _3339_/Y VGND VGND VPWR VPWR _5151_/A sky130_fd_sc_hd__buf_2
Xplace389 _5633_/B VGND VGND VPWR VPWR _5622_/B sky130_fd_sc_hd__buf_2
Xplace367 _4305_/B VGND VGND VPWR VPWR _4265_/B sky130_fd_sc_hd__buf_2
Xplace356 _4946_/S VGND VGND VPWR VPWR _4837_/S sky130_fd_sc_hd__buf_2
XFILLER_31_231 VGND VGND VPWR VPWR sky130_fd_sc_hd__fill_1
X_3871_ _6785_/Q _3922_/A2 _3888_/B1 _6873_/Q VGND VGND VPWR VPWR _3871_/X sky130_fd_sc_hd__a22o_2
X_6590_ _6622_/A VGND VGND VPWR VPWR _6590_/Y sky130_fd_sc_hd__inv_2
XTAP_TAPCELL_ROW_42_760 VGND VPWR sky130_fd_sc_hd__tapvpwrvgnd_1
X_7211_ _7405_/CLK _7211_/D _6491_/Y VGND VGND VPWR VPWR _7211_/Q sky130_fd_sc_hd__dfrtp_2
X_4423_ _7080_/Q _4265_/B _4432_/B1 _4422_/X VGND VGND VPWR VPWR _4649_/B sky130_fd_sc_hd__o211ai_2
XTAP_TAPCELL_ROW_113_1612 VGND VPWR sky130_fd_sc_hd__tapvpwrvgnd_1
XFILLER_113_520 VGND VGND VPWR VPWR sky130_fd_sc_hd__decap_3
X_7142_ _7144_/CLK _7142_/D _6422_/Y VGND VGND VPWR VPWR _7142_/Q sky130_fd_sc_hd__dfrtp_2
X_4354_ _7038_/Q _4488_/S _4437_/B1 _7385_/Q VGND VGND VPWR VPWR _4355_/B sky130_fd_sc_hd__a22o_2
XFILLER_113_553 VGND VGND VPWR VPWR sky130_fd_sc_hd__decap_3
XFILLER_113_564 VGND VGND VPWR VPWR sky130_fd_sc_hd__decap_3
XFILLER_59_629 VGND VGND VPWR VPWR sky130_fd_sc_hd__decap_3
X_7073_ _7404_/CLK _7073_/D _6353_/Y VGND VGND VPWR VPWR _7073_/Q sky130_fd_sc_hd__dfrtp_2
X_3305_ _5670_/A VGND VGND VPWR VPWR _3340_/B sky130_fd_sc_hd__inv_2
XFILLER_100_214 VGND VGND VPWR VPWR sky130_fd_sc_hd__decap_3
XFILLER_113_597 VGND VGND VPWR VPWR sky130_fd_sc_hd__decap_3
X_4285_ _7035_/Q _3562_/A _4285_/B1 _7382_/Q VGND VGND VPWR VPWR _4286_/B sky130_fd_sc_hd__a22o_2
XFILLER_104_15 VGND VGND VPWR VPWR sky130_fd_sc_hd__decap_3
XFILLER_67_662 VGND VGND VPWR VPWR sky130_fd_sc_hd__decap_3
XFILLER_86_459 VGND VGND VPWR VPWR sky130_fd_sc_hd__fill_2
XFILLER_54_312 VGND VGND VPWR VPWR sky130_fd_sc_hd__decap_3
XFILLER_67_673 VGND VGND VPWR VPWR sky130_fd_sc_hd__decap_3
XFILLER_73_109 VGND VGND VPWR VPWR sky130_fd_sc_hd__decap_3
XFILLER_82_610 VGND VGND VPWR VPWR sky130_fd_sc_hd__decap_3
XFILLER_27_559 VGND VGND VPWR VPWR sky130_fd_sc_hd__fill_1
XFILLER_54_345 VGND VGND VPWR VPWR sky130_fd_sc_hd__decap_3
XFILLER_82_643 VGND VGND VPWR VPWR sky130_fd_sc_hd__fill_1
XFILLER_82_654 VGND VGND VPWR VPWR sky130_fd_sc_hd__decap_3
XFILLER_14_209 VGND VGND VPWR VPWR sky130_fd_sc_hd__fill_2
XFILLER_42_507 VGND VGND VPWR VPWR sky130_fd_sc_hd__decap_3
XFILLER_42_529 VGND VGND VPWR VPWR sky130_fd_sc_hd__decap_3
XFILLER_82_687 VGND VGND VPWR VPWR sky130_fd_sc_hd__decap_3
X_6926_ _6966_/CLK _6926_/D VGND VGND VPWR VPWR _6926_/Q sky130_fd_sc_hd__dfxtp_2
XFILLER_35_570 VGND VGND VPWR VPWR sky130_fd_sc_hd__decap_3
XFILLER_54_389 VGND VGND VPWR VPWR sky130_fd_sc_hd__decap_3
XFILLER_81_175 VGND VGND VPWR VPWR sky130_fd_sc_hd__decap_3
XFILLER_22_220 VGND VGND VPWR VPWR sky130_fd_sc_hd__decap_3
Xfanout24 _6630_/A VGND VGND VPWR VPWR _6596_/A sky130_fd_sc_hd__buf_2
Xfanout35 _6636_/A VGND VGND VPWR VPWR _6624_/A sky130_fd_sc_hd__buf_2
Xfanout46 fanout47/X VGND VGND VPWR VPWR fanout46/X sky130_fd_sc_hd__clkdlybuf4s25_1
X_6857_ _7378_/CLK _6857_/D VGND VGND VPWR VPWR _6857_/Q sky130_fd_sc_hd__dfxtp_2
XFILLER_22_253 VGND VGND VPWR VPWR sky130_fd_sc_hd__fill_1
XFILLER_22_264 VGND VGND VPWR VPWR sky130_fd_sc_hd__decap_3
XFILLER_50_584 VGND VGND VPWR VPWR sky130_fd_sc_hd__decap_3
XFILLER_50_595 VGND VGND VPWR VPWR sky130_fd_sc_hd__decap_3
Xfanout57 _6582_/A VGND VGND VPWR VPWR _6645_/A sky130_fd_sc_hd__buf_1
Xfanout68 wire569/A VGND VGND VPWR VPWR _6557_/A sky130_fd_sc_hd__clkdlybuf4s25_1
X_6788_ _6965_/CLK _6788_/D VGND VGND VPWR VPWR _6788_/Q sky130_fd_sc_hd__dfxtp_2
XFILLER_108_303 VGND VGND VPWR VPWR sky130_fd_sc_hd__decap_3
XFILLER_108_325 VGND VGND VPWR VPWR sky130_fd_sc_hd__decap_3
XFILLER_6_419 VGND VGND VPWR VPWR sky130_fd_sc_hd__fill_1
XTAP_TAPCELL_ROW_20_487 VGND VPWR sky130_fd_sc_hd__tapvpwrvgnd_1
XFILLER_104_531 VGND VGND VPWR VPWR sky130_fd_sc_hd__fill_1
XFILLER_116_380 VGND VGND VPWR VPWR sky130_fd_sc_hd__fill_1
XFILLER_1_113 VGND VGND VPWR VPWR sky130_fd_sc_hd__decap_3
XFILLER_2_625 VGND VGND VPWR VPWR sky130_fd_sc_hd__decap_3
XFILLER_104_542 VGND VGND VPWR VPWR sky130_fd_sc_hd__decap_3
XFILLER_104_575 VGND VGND VPWR VPWR sky130_fd_sc_hd__decap_3
XFILLER_2_669 VGND VGND VPWR VPWR sky130_fd_sc_hd__decap_3
XFILLER_77_404 VGND VGND VPWR VPWR sky130_fd_sc_hd__decap_3
XFILLER_49_106 VGND VGND VPWR VPWR sky130_fd_sc_hd__fill_2
XFILLER_58_640 VGND VGND VPWR VPWR sky130_fd_sc_hd__decap_3
XFILLER_58_651 VGND VGND VPWR VPWR sky130_fd_sc_hd__decap_3
XFILLER_45_312 VGND VGND VPWR VPWR sky130_fd_sc_hd__fill_2
XFILLER_58_684 VGND VGND VPWR VPWR sky130_fd_sc_hd__decap_3
XFILLER_64_109 VGND VGND VPWR VPWR sky130_fd_sc_hd__fill_2
XFILLER_92_418 VGND VGND VPWR VPWR sky130_fd_sc_hd__fill_2
Xhold1160 _7230_/Q VGND VGND VPWR VPWR _5196_/A sky130_fd_sc_hd__dlygate4sd3_1
XFILLER_18_548 VGND VGND VPWR VPWR sky130_fd_sc_hd__decap_3
XFILLER_57_172 VGND VGND VPWR VPWR sky130_fd_sc_hd__decap_3
XFILLER_73_632 VGND VGND VPWR VPWR sky130_fd_sc_hd__decap_3
Xhold1171 _7137_/Q VGND VGND VPWR VPWR _5392_/A0 sky130_fd_sc_hd__dlygate4sd3_1
Xhold1182 _7400_/Q VGND VGND VPWR VPWR _3705_/A0 sky130_fd_sc_hd__dlygate4sd3_1
Xhold1193 _7333_/Q VGND VGND VPWR VPWR _4493_/A0 sky130_fd_sc_hd__dlygate4sd3_1
XFILLER_72_153 VGND VGND VPWR VPWR sky130_fd_sc_hd__fill_2
XFILLER_73_665 VGND VGND VPWR VPWR sky130_fd_sc_hd__decap_3
XFILLER_73_676 VGND VGND VPWR VPWR sky130_fd_sc_hd__decap_3
XTAP_TAPCELL_ROW_86_1279 VGND VPWR sky130_fd_sc_hd__tapvpwrvgnd_1
XFILLER_26_592 VGND VGND VPWR VPWR sky130_fd_sc_hd__decap_3
XFILLER_60_315 VGND VGND VPWR VPWR sky130_fd_sc_hd__decap_3
XFILLER_60_337 VGND VGND VPWR VPWR sky130_fd_sc_hd__fill_2
XFILLER_72_175 VGND VGND VPWR VPWR sky130_fd_sc_hd__fill_1
XFILLER_72_186 VGND VGND VPWR VPWR sky130_fd_sc_hd__decap_3
XFILLER_72_197 VGND VGND VPWR VPWR sky130_fd_sc_hd__decap_3
XTAP_TAPCELL_ROW_28_587 VGND VPWR sky130_fd_sc_hd__tapvpwrvgnd_1
XFILLER_41_551 VGND VGND VPWR VPWR sky130_fd_sc_hd__decap_3
XFILLER_60_348 VGND VGND VPWR VPWR sky130_fd_sc_hd__fill_1
XFILLER_110_80 VGND VGND VPWR VPWR sky130_fd_sc_hd__decap_3
XFILLER_41_573 VGND VGND VPWR VPWR sky130_fd_sc_hd__decap_3
XFILLER_9_213 VGND VGND VPWR VPWR sky130_fd_sc_hd__decap_3
XFILLER_70_51 VGND VGND VPWR VPWR sky130_fd_sc_hd__decap_3
XFILLER_9_257 VGND VGND VPWR VPWR sky130_fd_sc_hd__decap_3
Xclkload16 _7383_/CLK VGND VGND VPWR VPWR clkload16/Y sky130_fd_sc_hd__bufinv_16
Xclkload27 _7374_/CLK VGND VGND VPWR VPWR clkload27/X sky130_fd_sc_hd__clkbuf_1
XFILLER_5_452 VGND VGND VPWR VPWR sky130_fd_sc_hd__fill_2
XFILLER_48_6 VGND VGND VPWR VPWR sky130_fd_sc_hd__fill_1
XFILLER_5_496 VGND VGND VPWR VPWR sky130_fd_sc_hd__decap_3
XFILLER_68_404 VGND VGND VPWR VPWR sky130_fd_sc_hd__fill_2
XFILLER_110_501 VGND VGND VPWR VPWR sky130_fd_sc_hd__decap_3
XFILLER_68_415 VGND VGND VPWR VPWR sky130_fd_sc_hd__decap_3
XFILLER_110_545 VGND VGND VPWR VPWR sky130_fd_sc_hd__decap_3
XFILLER_95_256 VGND VGND VPWR VPWR sky130_fd_sc_hd__decap_3
X_4070_ _7339_/Q _4390_/B1 _4428_/B1 _7147_/Q VGND VGND VPWR VPWR _4070_/X sky130_fd_sc_hd__a22o_2
XFILLER_110_578 VGND VGND VPWR VPWR sky130_fd_sc_hd__decap_3
XFILLER_110_589 VGND VGND VPWR VPWR sky130_fd_sc_hd__decap_3
XFILLER_49_662 VGND VGND VPWR VPWR sky130_fd_sc_hd__decap_3
XFILLER_49_673 VGND VGND VPWR VPWR sky130_fd_sc_hd__decap_3
XFILLER_64_610 VGND VGND VPWR VPWR sky130_fd_sc_hd__decap_3
XFILLER_83_418 VGND VGND VPWR VPWR sky130_fd_sc_hd__decap_3
XFILLER_95_289 VGND VGND VPWR VPWR sky130_fd_sc_hd__decap_3
XFILLER_48_183 VGND VGND VPWR VPWR sky130_fd_sc_hd__decap_3
XFILLER_64_643 VGND VGND VPWR VPWR sky130_fd_sc_hd__fill_1
XFILLER_64_654 VGND VGND VPWR VPWR sky130_fd_sc_hd__decap_3
XFILLER_24_518 VGND VGND VPWR VPWR sky130_fd_sc_hd__fill_1
XFILLER_51_304 VGND VGND VPWR VPWR sky130_fd_sc_hd__decap_3
XFILLER_64_687 VGND VGND VPWR VPWR sky130_fd_sc_hd__decap_3
XFILLER_17_570 VGND VGND VPWR VPWR sky130_fd_sc_hd__decap_3
X_4972_ _5661_/B VGND VGND VPWR VPWR _4973_/B sky130_fd_sc_hd__inv_2
XTAP_TAPCELL_ROW_63_1010 VGND VPWR sky130_fd_sc_hd__tapvpwrvgnd_1
X_6711_ _7403_/CLK _6711_/D VGND VGND VPWR VPWR _6711_/Q sky130_fd_sc_hd__dfxtp_2
X_3923_ _3629_/A _3922_/X _3874_/A VGND VGND VPWR VPWR _3923_/X sky130_fd_sc_hd__a21o_2
XFILLER_32_573 VGND VGND VPWR VPWR sky130_fd_sc_hd__decap_3
X_6642_ _6642_/A VGND VGND VPWR VPWR _6642_/Y sky130_fd_sc_hd__inv_2
X_3854_ _3725_/X _3851_/X _3853_/X _3735_/X VGND VGND VPWR VPWR _3854_/X sky130_fd_sc_hd__a22o_2
XFILLER_32_595 VGND VGND VPWR VPWR sky130_fd_sc_hd__decap_3
X_6573_ _6638_/A VGND VGND VPWR VPWR _6573_/Y sky130_fd_sc_hd__inv_2
X_3785_ _6837_/Q _3891_/A2 _3890_/B1 _6832_/Q _3784_/X VGND VGND VPWR VPWR _3785_/X
+ sky130_fd_sc_hd__a221o_2
Xoutput510 _7412_/X VGND VGND VPWR VPWR instruction_out[30] sky130_fd_sc_hd__clkdlybuf4s25_1
Xoutput543 _3313_/B VGND VGND VPWR VPWR pc_out[3] sky130_fd_sc_hd__clkdlybuf4s25_1
Xoutput532 _6999_/Q VGND VGND VPWR VPWR pc_out[22] sky130_fd_sc_hd__clkdlybuf4s25_1
Xoutput521 _6989_/Q VGND VGND VPWR VPWR pc_out[12] sky130_fd_sc_hd__clkdlybuf4s25_1
X_4406_ _7402_/Q _4406_/A2 _4434_/B1 _7146_/Q _4405_/X VGND VGND VPWR VPWR _4406_/X
+ sky130_fd_sc_hd__a221o_2
X_7125_ _7349_/CLK _7125_/D _6405_/Y VGND VGND VPWR VPWR _7125_/Q sky130_fd_sc_hd__dfrtp_2
X_5386_ _5386_/A0 _4899_/X _5409_/S VGND VGND VPWR VPWR _7140_/D sky130_fd_sc_hd__mux2_2
XFILLER_99_573 VGND VGND VPWR VPWR sky130_fd_sc_hd__decap_3
XFILLER_101_501 VGND VGND VPWR VPWR sky130_fd_sc_hd__decap_3
XFILLER_101_523 VGND VGND VPWR VPWR sky130_fd_sc_hd__decap_3
XFILLER_115_36 VGND VGND VPWR VPWR sky130_fd_sc_hd__decap_3
XFILLER_59_415 VGND VGND VPWR VPWR sky130_fd_sc_hd__decap_3
X_4337_ _4394_/A _4337_/B _4336_/X VGND VGND VPWR VPWR _4365_/C sky130_fd_sc_hd__or3b_2
XFILLER_101_556 VGND VGND VPWR VPWR sky130_fd_sc_hd__decap_3
XFILLER_101_567 VGND VGND VPWR VPWR sky130_fd_sc_hd__decap_3
XFILLER_115_69 VGND VGND VPWR VPWR sky130_fd_sc_hd__decap_3
XFILLER_86_245 VGND VGND VPWR VPWR sky130_fd_sc_hd__decap_3
X_7056_ _7311_/CLK _7056_/D _6336_/Y VGND VGND VPWR VPWR _7056_/Q sky130_fd_sc_hd__dfstp_2
X_4268_ _7198_/Q _3964_/S _4346_/B1 _7390_/Q VGND VGND VPWR VPWR _4268_/X sky130_fd_sc_hd__a22o_2
XFILLER_67_470 VGND VGND VPWR VPWR sky130_fd_sc_hd__decap_3
XFILLER_74_407 VGND VGND VPWR VPWR sky130_fd_sc_hd__decap_3
XFILLER_74_429 VGND VGND VPWR VPWR sky130_fd_sc_hd__decap_3
XFILLER_27_323 VGND VGND VPWR VPWR sky130_fd_sc_hd__decap_3
XFILLER_55_632 VGND VGND VPWR VPWR sky130_fd_sc_hd__decap_3
XFILLER_67_481 VGND VGND VPWR VPWR sky130_fd_sc_hd__fill_2
XFILLER_67_492 VGND VGND VPWR VPWR sky130_fd_sc_hd__decap_3
X_4199_ _4380_/A _4380_/B VGND VGND VPWR VPWR _4381_/A sky130_fd_sc_hd__nand2_2
XFILLER_55_665 VGND VGND VPWR VPWR sky130_fd_sc_hd__decap_3
XFILLER_55_676 VGND VGND VPWR VPWR sky130_fd_sc_hd__decap_3
XFILLER_15_529 VGND VGND VPWR VPWR sky130_fd_sc_hd__decap_3
XFILLER_42_337 VGND VGND VPWR VPWR sky130_fd_sc_hd__decap_3
XFILLER_54_164 VGND VGND VPWR VPWR sky130_fd_sc_hd__decap_3
XFILLER_70_613 VGND VGND VPWR VPWR sky130_fd_sc_hd__decap_3
XFILLER_23_540 VGND VGND VPWR VPWR sky130_fd_sc_hd__decap_3
XFILLER_70_657 VGND VGND VPWR VPWR sky130_fd_sc_hd__decap_3
X_6909_ _6978_/CLK _6909_/D VGND VGND VPWR VPWR _6909_/Q sky130_fd_sc_hd__dfxtp_2
XTAP_TAPCELL_ROW_25_557 VGND VPWR sky130_fd_sc_hd__tapvpwrvgnd_1
XTAP_TAPCELL_ROW_25_546 VGND VPWR sky130_fd_sc_hd__tapvpwrvgnd_1
XFILLER_23_573 VGND VGND VPWR VPWR sky130_fd_sc_hd__decap_3
XTAP_TAPCELL_ROW_53_888 VGND VPWR sky130_fd_sc_hd__tapvpwrvgnd_1
XFILLER_10_212 VGND VGND VPWR VPWR sky130_fd_sc_hd__decap_3
XFILLER_109_612 VGND VGND VPWR VPWR sky130_fd_sc_hd__decap_3
XFILLER_109_623 VGND VGND VPWR VPWR sky130_fd_sc_hd__decap_3
XFILLER_10_256 VGND VGND VPWR VPWR sky130_fd_sc_hd__fill_1
XFILLER_109_656 VGND VGND VPWR VPWR sky130_fd_sc_hd__decap_3
XFILLER_2_455 VGND VGND VPWR VPWR sky130_fd_sc_hd__decap_3
XFILLER_2_477 VGND VGND VPWR VPWR sky130_fd_sc_hd__decap_3
XFILLER_77_201 VGND VGND VPWR VPWR sky130_fd_sc_hd__fill_1
XFILLER_77_256 VGND VGND VPWR VPWR sky130_fd_sc_hd__decap_3
XFILLER_1_15 VGND VGND VPWR VPWR sky130_fd_sc_hd__decap_3
XFILLER_37_109 VGND VGND VPWR VPWR sky130_fd_sc_hd__decap_3
XFILLER_46_610 VGND VGND VPWR VPWR sky130_fd_sc_hd__decap_3
XFILLER_58_470 VGND VGND VPWR VPWR sky130_fd_sc_hd__decap_3
XFILLER_92_215 VGND VGND VPWR VPWR sky130_fd_sc_hd__decap_3
XTAP_TAPCELL_ROW_88_1308 VGND VPWR sky130_fd_sc_hd__tapvpwrvgnd_1
XFILLER_46_643 VGND VGND VPWR VPWR sky130_fd_sc_hd__fill_1
XFILLER_18_345 VGND VGND VPWR VPWR sky130_fd_sc_hd__decap_3
XFILLER_46_654 VGND VGND VPWR VPWR sky130_fd_sc_hd__decap_3
XFILLER_33_337 VGND VGND VPWR VPWR sky130_fd_sc_hd__decap_3
XFILLER_46_687 VGND VGND VPWR VPWR sky130_fd_sc_hd__decap_3
XFILLER_61_635 VGND VGND VPWR VPWR sky130_fd_sc_hd__decap_3
XFILLER_33_348 VGND VGND VPWR VPWR sky130_fd_sc_hd__decap_3
XFILLER_61_668 VGND VGND VPWR VPWR sky130_fd_sc_hd__decap_3
XFILLER_61_679 VGND VGND VPWR VPWR sky130_fd_sc_hd__decap_3
XFILLER_14_551 VGND VGND VPWR VPWR sky130_fd_sc_hd__decap_3
XFILLER_14_584 VGND VGND VPWR VPWR sky130_fd_sc_hd__decap_3
XFILLER_81_72 VGND VGND VPWR VPWR sky130_fd_sc_hd__decap_3
XFILLER_14_595 VGND VGND VPWR VPWR sky130_fd_sc_hd__decap_3
XFILLER_41_370 VGND VGND VPWR VPWR sky130_fd_sc_hd__decap_3
XTAP_TAPCELL_ROW_99_1437 VGND VPWR sky130_fd_sc_hd__tapvpwrvgnd_1
X_3570_ _7157_/Q _3409_/X _4337_/B _3469_/B _3469_/A VGND VGND VPWR VPWR _3570_/X
+ sky130_fd_sc_hd__a2111o_2
XFILLER_115_615 VGND VGND VPWR VPWR sky130_fd_sc_hd__fill_1
XFILLER_115_626 VGND VGND VPWR VPWR sky130_fd_sc_hd__decap_3
XFILLER_114_103 VGND VGND VPWR VPWR sky130_fd_sc_hd__decap_3
XFILLER_115_659 VGND VGND VPWR VPWR sky130_fd_sc_hd__decap_3
X_5240_ _4788_/A _4788_/B _5238_/X hold965/X VGND VGND VPWR VPWR _7210_/D sky130_fd_sc_hd__a22o_2
XFILLER_114_147 VGND VGND VPWR VPWR sky130_fd_sc_hd__decap_3
XFILLER_68_212 VGND VGND VPWR VPWR sky130_fd_sc_hd__decap_3
XFILLER_96_521 VGND VGND VPWR VPWR sky130_fd_sc_hd__decap_3
X_5171_ _5171_/A _5177_/B VGND VGND VPWR VPWR _7242_/D sky130_fd_sc_hd__and2_2
XPHY_EDGE_ROW_18_Right_18 VGND VGND VPWR VPWR sky130_fd_sc_hd__decap_3
XFILLER_96_554 VGND VGND VPWR VPWR sky130_fd_sc_hd__decap_3
X_4122_ _7204_/Q _3958_/S _4269_/B1 _7049_/Q _4121_/X VGND VGND VPWR VPWR _4122_/X
+ sky130_fd_sc_hd__a221o_2
XFILLER_56_407 VGND VGND VPWR VPWR sky130_fd_sc_hd__decap_3
XFILLER_83_204 VGND VGND VPWR VPWR sky130_fd_sc_hd__decap_3
XFILLER_96_587 VGND VGND VPWR VPWR sky130_fd_sc_hd__fill_1
XFILLER_96_598 VGND VGND VPWR VPWR sky130_fd_sc_hd__decap_3
X_4053_ _4054_/A _4456_/A VGND VGND VPWR VPWR _4055_/A sky130_fd_sc_hd__nor2_2
XFILLER_110_397 VGND VGND VPWR VPWR sky130_fd_sc_hd__decap_3
XFILLER_37_632 VGND VGND VPWR VPWR sky130_fd_sc_hd__decap_3
XFILLER_49_481 VGND VGND VPWR VPWR sky130_fd_sc_hd__fill_2
XFILLER_37_665 VGND VGND VPWR VPWR sky130_fd_sc_hd__decap_3
XFILLER_37_676 VGND VGND VPWR VPWR sky130_fd_sc_hd__decap_3
XTAP_TAPCELL_ROW_108_1544 VGND VPWR sky130_fd_sc_hd__tapvpwrvgnd_1
XFILLER_24_304 VGND VGND VPWR VPWR sky130_fd_sc_hd__decap_3
XFILLER_24_326 VGND VGND VPWR VPWR sky130_fd_sc_hd__decap_3
XFILLER_52_613 VGND VGND VPWR VPWR sky130_fd_sc_hd__decap_3
XFILLER_64_473 VGND VGND VPWR VPWR sky130_fd_sc_hd__decap_3
XFILLER_24_359 VGND VGND VPWR VPWR sky130_fd_sc_hd__decap_3
XFILLER_36_197 VGND VGND VPWR VPWR sky130_fd_sc_hd__fill_1
XFILLER_52_657 VGND VGND VPWR VPWR sky130_fd_sc_hd__decap_3
XFILLER_91_292 VGND VGND VPWR VPWR sky130_fd_sc_hd__fill_1
X_4955_ _4970_/A1 _4639_/A _4950_/A _5033_/B2 VGND VGND VPWR VPWR _4955_/X sky130_fd_sc_hd__a22o_2
XPHY_EDGE_ROW_27_Right_27 VGND VGND VPWR VPWR sky130_fd_sc_hd__decap_3
XFILLER_51_156 VGND VGND VPWR VPWR sky130_fd_sc_hd__decap_3
XFILLER_51_178 VGND VGND VPWR VPWR sky130_fd_sc_hd__decap_3
X_3906_ _6917_/Q _3921_/A2 _5660_/B _6691_/Q VGND VGND VPWR VPWR _3906_/X sky130_fd_sc_hd__a22o_2
XTAP_TAPCELL_ROW_22_516 VGND VPWR sky130_fd_sc_hd__tapvpwrvgnd_1
XFILLER_60_690 VGND VGND VPWR VPWR sky130_fd_sc_hd__fill_1
X_4886_ _4886_/A _4890_/B _4886_/C VGND VGND VPWR VPWR _4886_/X sky130_fd_sc_hd__or3_2
XTAP_TAPCELL_ROW_50_847 VGND VPWR sky130_fd_sc_hd__tapvpwrvgnd_1
XFILLER_20_554 VGND VGND VPWR VPWR sky130_fd_sc_hd__decap_3
X_6625_ _6625_/A VGND VGND VPWR VPWR _6625_/Y sky130_fd_sc_hd__inv_2
X_3837_ _6755_/Q _3890_/B1 _3852_/B1 _6767_/Q VGND VGND VPWR VPWR _3837_/X sky130_fd_sc_hd__a22o_2
XFILLER_20_587 VGND VGND VPWR VPWR sky130_fd_sc_hd__fill_1
XFILLER_20_598 VGND VGND VPWR VPWR sky130_fd_sc_hd__decap_3
X_6556_ _6557_/A VGND VGND VPWR VPWR _6556_/Y sky130_fd_sc_hd__inv_2
X_3768_ _6931_/Q _3768_/A2 _3926_/B1 _6795_/Q VGND VGND VPWR VPWR _3768_/X sky130_fd_sc_hd__a22o_2
XFILLER_106_604 VGND VGND VPWR VPWR sky130_fd_sc_hd__decap_3
XFILLER_3_208 VGND VGND VPWR VPWR sky130_fd_sc_hd__decap_3
XFILLER_105_125 VGND VGND VPWR VPWR sky130_fd_sc_hd__fill_1
XFILLER_106_637 VGND VGND VPWR VPWR sky130_fd_sc_hd__decap_3
XFILLER_106_648 VGND VGND VPWR VPWR sky130_fd_sc_hd__decap_3
X_6487_ _6649_/A VGND VGND VPWR VPWR _6487_/Y sky130_fd_sc_hd__inv_2
X_3699_ _6713_/Q _3917_/A2 _3902_/B1 _6891_/Q VGND VGND VPWR VPWR _3699_/X sky130_fd_sc_hd__a22o_2
XFILLER_105_147 VGND VGND VPWR VPWR sky130_fd_sc_hd__fill_1
XFILLER_105_169 VGND VGND VPWR VPWR sky130_fd_sc_hd__decap_3
XPHY_EDGE_ROW_36_Right_36 VGND VGND VPWR VPWR sky130_fd_sc_hd__decap_3
XFILLER_114_681 VGND VGND VPWR VPWR sky130_fd_sc_hd__decap_3
X_5369_ _5369_/A0 _4752_/X _5383_/S VGND VGND VPWR VPWR _7148_/D sky130_fd_sc_hd__mux2_2
XFILLER_59_234 VGND VGND VPWR VPWR sky130_fd_sc_hd__decap_3
XFILLER_87_543 VGND VGND VPWR VPWR sky130_fd_sc_hd__decap_3
X_7108_ _7328_/CLK _7108_/D _6388_/Y VGND VGND VPWR VPWR _7108_/Q sky130_fd_sc_hd__dfrtp_2
XFILLER_19_44 VGND VGND VPWR VPWR sky130_fd_sc_hd__decap_3
XFILLER_87_576 VGND VGND VPWR VPWR sky130_fd_sc_hd__decap_3
X_7039_ _7398_/CLK _7039_/D _6319_/Y VGND VGND VPWR VPWR _7039_/Q sky130_fd_sc_hd__dfrtp_2
XFILLER_101_386 VGND VGND VPWR VPWR sky130_fd_sc_hd__fill_2
XFILLER_19_77 VGND VGND VPWR VPWR sky130_fd_sc_hd__decap_3
XFILLER_28_610 VGND VGND VPWR VPWR sky130_fd_sc_hd__decap_3
XFILLER_28_643 VGND VGND VPWR VPWR sky130_fd_sc_hd__fill_1
XFILLER_74_215 VGND VGND VPWR VPWR sky130_fd_sc_hd__decap_3
XTAP_TAPCELL_ROW_58_947 VGND VPWR sky130_fd_sc_hd__tapvpwrvgnd_1
XFILLER_27_131 VGND VGND VPWR VPWR sky130_fd_sc_hd__fill_1
XFILLER_28_654 VGND VGND VPWR VPWR sky130_fd_sc_hd__decap_3
XFILLER_74_259 VGND VGND VPWR VPWR sky130_fd_sc_hd__decap_3
XTAP_TAPCELL_ROW_2_274 VGND VPWR sky130_fd_sc_hd__tapvpwrvgnd_1
XFILLER_28_687 VGND VGND VPWR VPWR sky130_fd_sc_hd__decap_3
XFILLER_42_112 VGND VGND VPWR VPWR sky130_fd_sc_hd__decap_3
XFILLER_43_635 VGND VGND VPWR VPWR sky130_fd_sc_hd__decap_3
XFILLER_70_421 VGND VGND VPWR VPWR sky130_fd_sc_hd__fill_1
XPHY_EDGE_ROW_45_Right_45 VGND VGND VPWR VPWR sky130_fd_sc_hd__decap_3
XFILLER_43_668 VGND VGND VPWR VPWR sky130_fd_sc_hd__decap_3
XTAP_TAPCELL_ROW_83_1249 VGND VPWR sky130_fd_sc_hd__tapvpwrvgnd_1
XFILLER_43_679 VGND VGND VPWR VPWR sky130_fd_sc_hd__decap_3
XFILLER_11_532 VGND VGND VPWR VPWR sky130_fd_sc_hd__decap_3
XFILLER_51_20 VGND VGND VPWR VPWR sky130_fd_sc_hd__fill_2
XFILLER_11_576 VGND VGND VPWR VPWR sky130_fd_sc_hd__decap_3
XFILLER_7_514 VGND VGND VPWR VPWR sky130_fd_sc_hd__decap_3
XFILLER_109_420 VGND VGND VPWR VPWR sky130_fd_sc_hd__decap_3
XFILLER_7_547 VGND VGND VPWR VPWR sky130_fd_sc_hd__decap_3
XFILLER_109_464 VGND VGND VPWR VPWR sky130_fd_sc_hd__decap_3
XFILLER_109_497 VGND VGND VPWR VPWR sky130_fd_sc_hd__decap_3
XPHY_EDGE_ROW_54_Right_54 VGND VGND VPWR VPWR sky130_fd_sc_hd__decap_3
XFILLER_112_607 VGND VGND VPWR VPWR sky130_fd_sc_hd__decap_3
XTAP_TAPCELL_ROW_94_1378 VGND VPWR sky130_fd_sc_hd__tapvpwrvgnd_1
XFILLER_78_521 VGND VGND VPWR VPWR sky130_fd_sc_hd__decap_3
XFILLER_111_128 VGND VGND VPWR VPWR sky130_fd_sc_hd__decap_3
XFILLER_78_554 VGND VGND VPWR VPWR sky130_fd_sc_hd__decap_3
XFILLER_76_61 VGND VGND VPWR VPWR sky130_fd_sc_hd__decap_3
XFILLER_78_587 VGND VGND VPWR VPWR sky130_fd_sc_hd__fill_1
XFILLER_19_632 VGND VGND VPWR VPWR sky130_fd_sc_hd__decap_3
XFILLER_65_215 VGND VGND VPWR VPWR sky130_fd_sc_hd__fill_2
XFILLER_65_237 VGND VGND VPWR VPWR sky130_fd_sc_hd__decap_3
XFILLER_78_598 VGND VGND VPWR VPWR sky130_fd_sc_hd__decap_3
XFILLER_93_535 VGND VGND VPWR VPWR sky130_fd_sc_hd__decap_3
XFILLER_19_665 VGND VGND VPWR VPWR sky130_fd_sc_hd__decap_3
XFILLER_19_676 VGND VGND VPWR VPWR sky130_fd_sc_hd__decap_3
XFILLER_93_579 VGND VGND VPWR VPWR sky130_fd_sc_hd__decap_3
XPHY_EDGE_ROW_63_Right_63 VGND VGND VPWR VPWR sky130_fd_sc_hd__decap_3
XFILLER_34_613 VGND VGND VPWR VPWR sky130_fd_sc_hd__decap_3
XFILLER_61_410 VGND VGND VPWR VPWR sky130_fd_sc_hd__decap_3
XFILLER_34_657 VGND VGND VPWR VPWR sky130_fd_sc_hd__decap_3
XFILLER_73_281 VGND VGND VPWR VPWR sky130_fd_sc_hd__decap_3
XFILLER_33_189 VGND VGND VPWR VPWR sky130_fd_sc_hd__fill_2
XFILLER_42_690 VGND VGND VPWR VPWR sky130_fd_sc_hd__fill_1
X_4740_ _4610_/A _4765_/B _4611_/Y _4762_/A _4948_/A VGND VGND VPWR VPWR _4740_/X
+ sky130_fd_sc_hd__a221o_2
XTAP_TAPCELL_ROW_103_1485 VGND VPWR sky130_fd_sc_hd__tapvpwrvgnd_1
X_4671_ _6991_/Q _4671_/B VGND VGND VPWR VPWR _4982_/B sky130_fd_sc_hd__and2_2
X_7390_ _7398_/CLK _7390_/D _6670_/Y VGND VGND VPWR VPWR _7390_/Q sky130_fd_sc_hd__dfrtp_2
X_6410_ _6602_/A VGND VGND VPWR VPWR _6410_/Y sky130_fd_sc_hd__inv_2
X_3622_ _4852_/A _5057_/A VGND VGND VPWR VPWR _3635_/B sky130_fd_sc_hd__nand2_2
X_6341_ _6628_/A VGND VGND VPWR VPWR _6341_/Y sky130_fd_sc_hd__inv_2
XPHY_EDGE_ROW_72_Right_72 VGND VGND VPWR VPWR sky130_fd_sc_hd__decap_3
XFILLER_115_423 VGND VGND VPWR VPWR sky130_fd_sc_hd__decap_3
X_3553_ _3469_/A _3469_/B _3449_/A _7253_/Q _3365_/A VGND VGND VPWR VPWR _3553_/X
+ sky130_fd_sc_hd__o2111a_2
XFILLER_115_467 VGND VGND VPWR VPWR sky130_fd_sc_hd__decap_3
X_6272_ _6651_/A VGND VGND VPWR VPWR _6272_/Y sky130_fd_sc_hd__inv_2
X_3484_ _4394_/A _4337_/B _3482_/Y _5153_/B VGND VGND VPWR VPWR _3485_/C sky130_fd_sc_hd__o31a_2
XFILLER_102_106 VGND VGND VPWR VPWR sky130_fd_sc_hd__decap_3
XFILLER_103_629 VGND VGND VPWR VPWR sky130_fd_sc_hd__decap_3
X_5223_ _5223_/A _5225_/B VGND VGND VPWR VPWR _7217_/D sky130_fd_sc_hd__and2_2
XFILLER_102_139 VGND VGND VPWR VPWR sky130_fd_sc_hd__fill_1
XFILLER_69_532 VGND VGND VPWR VPWR sky130_fd_sc_hd__decap_3
X_5154_ _5152_/Y _5153_/X _5647_/A VGND VGND VPWR VPWR _5154_/Y sky130_fd_sc_hd__a21oi_2
XFILLER_111_662 VGND VGND VPWR VPWR sky130_fd_sc_hd__decap_3
XFILLER_111_673 VGND VGND VPWR VPWR sky130_fd_sc_hd__decap_3
XFILLER_29_407 VGND VGND VPWR VPWR sky130_fd_sc_hd__decap_3
XFILLER_69_576 VGND VGND VPWR VPWR sky130_fd_sc_hd__decap_3
X_4105_ _7205_/Q _3958_/S _4419_/B1 _7397_/Q _4104_/X VGND VGND VPWR VPWR _4105_/X
+ sky130_fd_sc_hd__a221o_2
XPHY_EDGE_ROW_16_Left_133 VGND VGND VPWR VPWR sky130_fd_sc_hd__decap_3
XFILLER_110_161 VGND VGND VPWR VPWR sky130_fd_sc_hd__decap_3
XFILLER_56_226 VGND VGND VPWR VPWR sky130_fd_sc_hd__fill_1
X_5085_ _5086_/A _5085_/A2 _5084_/X VGND VGND VPWR VPWR _5085_/X sky130_fd_sc_hd__o21ba_2
XPHY_EDGE_ROW_81_Right_81 VGND VGND VPWR VPWR sky130_fd_sc_hd__decap_3
XFILLER_110_194 VGND VGND VPWR VPWR sky130_fd_sc_hd__fill_2
XFILLER_112_15 VGND VGND VPWR VPWR sky130_fd_sc_hd__decap_3
XFILLER_56_248 VGND VGND VPWR VPWR sky130_fd_sc_hd__decap_3
XFILLER_56_259 VGND VGND VPWR VPWR sky130_fd_sc_hd__decap_3
XFILLER_84_557 VGND VGND VPWR VPWR sky130_fd_sc_hd__decap_3
X_4036_ _7310_/Q _4837_/S _4434_/A2 _7118_/Q _4035_/X VGND VGND VPWR VPWR _4036_/X
+ sky130_fd_sc_hd__a221o_2
XTAP_TAPCELL_ROW_55_917 VGND VPWR sky130_fd_sc_hd__tapvpwrvgnd_1
XTAP_TAPCELL_ROW_55_906 VGND VPWR sky130_fd_sc_hd__tapvpwrvgnd_1
XFILLER_112_59 VGND VGND VPWR VPWR sky130_fd_sc_hd__decap_3
XFILLER_25_635 VGND VGND VPWR VPWR sky130_fd_sc_hd__decap_3
XFILLER_25_668 VGND VGND VPWR VPWR sky130_fd_sc_hd__decap_3
XFILLER_52_421 VGND VGND VPWR VPWR sky130_fd_sc_hd__decap_3
XFILLER_64_292 VGND VGND VPWR VPWR sky130_fd_sc_hd__decap_3
XTAP_TAPCELL_ROW_69_1082 VGND VPWR sky130_fd_sc_hd__tapvpwrvgnd_1
XFILLER_12_307 VGND VGND VPWR VPWR sky130_fd_sc_hd__fill_1
XFILLER_24_156 VGND VGND VPWR VPWR sky130_fd_sc_hd__decap_3
XFILLER_25_679 VGND VGND VPWR VPWR sky130_fd_sc_hd__decap_3
XFILLER_40_616 VGND VGND VPWR VPWR sky130_fd_sc_hd__decap_3
XFILLER_52_454 VGND VGND VPWR VPWR sky130_fd_sc_hd__decap_3
XTAP_TAPCELL_ROW_35_674 VGND VPWR sky130_fd_sc_hd__tapvpwrvgnd_1
X_4938_ _4938_/A _4938_/B VGND VGND VPWR VPWR _4938_/Y sky130_fd_sc_hd__nor2_2
XFILLER_20_340 VGND VGND VPWR VPWR sky130_fd_sc_hd__decap_3
X_4869_ _6999_/Q _4858_/B _4983_/A VGND VGND VPWR VPWR _4870_/B sky130_fd_sc_hd__o21ai_2
XPHY_EDGE_ROW_25_Left_142 VGND VGND VPWR VPWR sky130_fd_sc_hd__decap_3
X_6608_ _6608_/A VGND VGND VPWR VPWR _6608_/Y sky130_fd_sc_hd__inv_2
XPHY_EDGE_ROW_90_Right_90 VGND VGND VPWR VPWR sky130_fd_sc_hd__decap_3
XFILLER_115_6 VGND VGND VPWR VPWR sky130_fd_sc_hd__decap_3
XFILLER_21_89 VGND VGND VPWR VPWR sky130_fd_sc_hd__decap_3
XFILLER_4_528 VGND VGND VPWR VPWR sky130_fd_sc_hd__decap_3
XFILLER_4_539 VGND VGND VPWR VPWR sky130_fd_sc_hd__decap_3
X_6539_ _6633_/A VGND VGND VPWR VPWR _6539_/Y sky130_fd_sc_hd__inv_2
XFILLER_106_445 VGND VGND VPWR VPWR sky130_fd_sc_hd__decap_3
XFILLER_106_489 VGND VGND VPWR VPWR sky130_fd_sc_hd__decap_3
XFILLER_102_640 VGND VGND VPWR VPWR sky130_fd_sc_hd__decap_3
XTAP_TAPCELL_ROW_7_333 VGND VPWR sky130_fd_sc_hd__tapvpwrvgnd_1
XPHY_EDGE_ROW_34_Left_151 VGND VGND VPWR VPWR sky130_fd_sc_hd__decap_3
XFILLER_102_651 VGND VGND VPWR VPWR sky130_fd_sc_hd__decap_3
XFILLER_87_340 VGND VGND VPWR VPWR sky130_fd_sc_hd__decap_3
XFILLER_101_172 VGND VGND VPWR VPWR sky130_fd_sc_hd__decap_3
XFILLER_102_684 VGND VGND VPWR VPWR sky130_fd_sc_hd__decap_3
XFILLER_47_248 VGND VGND VPWR VPWR sky130_fd_sc_hd__decap_3
XFILLER_75_579 VGND VGND VPWR VPWR sky130_fd_sc_hd__decap_3
XFILLER_16_613 VGND VGND VPWR VPWR sky130_fd_sc_hd__decap_3
XFILLER_43_410 VGND VGND VPWR VPWR sky130_fd_sc_hd__decap_3
XFILLER_55_270 VGND VGND VPWR VPWR sky130_fd_sc_hd__decap_3
XFILLER_62_218 VGND VGND VPWR VPWR sky130_fd_sc_hd__decap_3
XFILLER_16_657 VGND VGND VPWR VPWR sky130_fd_sc_hd__decap_3
XFILLER_43_443 VGND VGND VPWR VPWR sky130_fd_sc_hd__decap_3
XFILLER_55_281 VGND VGND VPWR VPWR sky130_fd_sc_hd__decap_3
XFILLER_102_70 VGND VGND VPWR VPWR sky130_fd_sc_hd__decap_3
XFILLER_24_690 VGND VGND VPWR VPWR sky130_fd_sc_hd__fill_1
XFILLER_31_638 VGND VGND VPWR VPWR sky130_fd_sc_hd__decap_3
XFILLER_62_41 VGND VGND VPWR VPWR sky130_fd_sc_hd__fill_1
XFILLER_70_284 VGND VGND VPWR VPWR sky130_fd_sc_hd__decap_3
XPHY_EDGE_ROW_43_Left_160 VGND VGND VPWR VPWR sky130_fd_sc_hd__decap_3
XFILLER_11_340 VGND VGND VPWR VPWR sky130_fd_sc_hd__decap_3
XFILLER_7_333 VGND VGND VPWR VPWR sky130_fd_sc_hd__decap_3
XTAP_TAPCELL_ROW_96_1407 VGND VPWR sky130_fd_sc_hd__tapvpwrvgnd_1
XFILLER_7_366 VGND VGND VPWR VPWR sky130_fd_sc_hd__decap_3
XFILLER_112_415 VGND VGND VPWR VPWR sky130_fd_sc_hd__decap_3
XFILLER_3_550 VGND VGND VPWR VPWR sky130_fd_sc_hd__decap_3
XFILLER_3_561 VGND VGND VPWR VPWR sky130_fd_sc_hd__decap_3
XFILLER_98_616 VGND VGND VPWR VPWR sky130_fd_sc_hd__decap_3
XFILLER_112_448 VGND VGND VPWR VPWR sky130_fd_sc_hd__decap_3
XFILLER_3_594 VGND VGND VPWR VPWR sky130_fd_sc_hd__decap_3
XFILLER_97_159 VGND VGND VPWR VPWR sky130_fd_sc_hd__decap_3
XFILLER_66_557 VGND VGND VPWR VPWR sky130_fd_sc_hd__decap_3
XFILLER_81_505 VGND VGND VPWR VPWR sky130_fd_sc_hd__fill_1
XFILLER_93_332 VGND VGND VPWR VPWR sky130_fd_sc_hd__decap_3
XFILLER_93_354 VGND VGND VPWR VPWR sky130_fd_sc_hd__fill_2
XFILLER_19_462 VGND VGND VPWR VPWR sky130_fd_sc_hd__decap_3
XFILLER_81_527 VGND VGND VPWR VPWR sky130_fd_sc_hd__decap_3
XTAP_TAPCELL_ROW_105_1514 VGND VPWR sky130_fd_sc_hd__tapvpwrvgnd_1
XFILLER_34_421 VGND VGND VPWR VPWR sky130_fd_sc_hd__fill_1
XFILLER_34_432 VGND VGND VPWR VPWR sky130_fd_sc_hd__fill_1
XFILLER_46_281 VGND VGND VPWR VPWR sky130_fd_sc_hd__decap_3
X_6890_ _7403_/CLK _6890_/D VGND VGND VPWR VPWR _6890_/Q sky130_fd_sc_hd__dfxtp_2
XFILLER_22_616 VGND VGND VPWR VPWR sky130_fd_sc_hd__decap_3
XFILLER_61_284 VGND VGND VPWR VPWR sky130_fd_sc_hd__decap_3
XTAP_TAPCELL_ROW_32_633 VGND VPWR sky130_fd_sc_hd__tapvpwrvgnd_1
XFILLER_21_148 VGND VGND VPWR VPWR sky130_fd_sc_hd__decap_3
XFILLER_21_159 VGND VGND VPWR VPWR sky130_fd_sc_hd__decap_3
X_4723_ _3536_/B _4720_/A _4721_/Y _4970_/A1 VGND VGND VPWR VPWR _4723_/X sky130_fd_sc_hd__a22o_2
XTAP_TAPCELL_ROW_60_975 VGND VPWR sky130_fd_sc_hd__tapvpwrvgnd_1
XFILLER_30_660 VGND VGND VPWR VPWR sky130_fd_sc_hd__decap_3
X_4654_ _4646_/Y _4647_/X _4653_/Y _4788_/B VGND VGND VPWR VPWR _4762_/A sky130_fd_sc_hd__a211o_2
XTAP_TAPCELL_ROW_12_390 VGND VPWR sky130_fd_sc_hd__tapvpwrvgnd_1
X_7373_ _7406_/CLK _7373_/D _6653_/Y VGND VGND VPWR VPWR _7373_/Q sky130_fd_sc_hd__dfrtp_2
Xhold801 _6800_/Q VGND VGND VPWR VPWR _6800_/D sky130_fd_sc_hd__dlygate4sd3_1
Xhold812 _6939_/Q VGND VGND VPWR VPWR _6939_/D sky130_fd_sc_hd__dlygate4sd3_1
X_4585_ _4585_/A _4595_/B VGND VGND VPWR VPWR _7288_/D sky130_fd_sc_hd__and2_2
X_3605_ _3621_/A _3621_/B VGND VGND VPWR VPWR _3605_/Y sky130_fd_sc_hd__nor2b_2
XTAP_TAPCELL_ROW_116_1643 VGND VPWR sky130_fd_sc_hd__tapvpwrvgnd_1
Xhold823 _6882_/Q VGND VGND VPWR VPWR _6882_/D sky130_fd_sc_hd__dlygate4sd3_1
Xhold834 _6914_/Q VGND VGND VPWR VPWR _6914_/D sky130_fd_sc_hd__dlygate4sd3_1
Xhold845 _7056_/Q VGND VGND VPWR VPWR _7056_/D sky130_fd_sc_hd__dlygate4sd3_1
Xmax_cap553 _5084_/B VGND VGND VPWR VPWR _5085_/A2 sky130_fd_sc_hd__clkdlybuf4s25_1
X_6324_ _6642_/A VGND VGND VPWR VPWR _6324_/Y sky130_fd_sc_hd__inv_2
X_3536_ _4614_/A _3536_/B VGND VGND VPWR VPWR _3536_/Y sky130_fd_sc_hd__nand2_2
XTAP_TAPCELL_ROW_116_1654 VGND VPWR sky130_fd_sc_hd__tapvpwrvgnd_1
XFILLER_107_15 VGND VGND VPWR VPWR sky130_fd_sc_hd__decap_3
XFILLER_107_48 VGND VGND VPWR VPWR sky130_fd_sc_hd__decap_3
XFILLER_115_275 VGND VGND VPWR VPWR sky130_fd_sc_hd__decap_3
XFILLER_88_115 VGND VGND VPWR VPWR sky130_fd_sc_hd__decap_3
XFILLER_89_638 VGND VGND VPWR VPWR sky130_fd_sc_hd__decap_3
Xhold856 _7116_/Q VGND VGND VPWR VPWR _7116_/D sky130_fd_sc_hd__dlygate4sd3_1
Xhold867 _7111_/Q VGND VGND VPWR VPWR _7111_/D sky130_fd_sc_hd__dlygate4sd3_1
Xhold878 _7072_/Q VGND VGND VPWR VPWR _7072_/D sky130_fd_sc_hd__dlygate4sd3_1
Xhold889 _7097_/Q VGND VGND VPWR VPWR _7097_/D sky130_fd_sc_hd__dlygate4sd3_1
Xmax_cap575 _6350_/A VGND VGND VPWR VPWR fanout73/A sky130_fd_sc_hd__buf_2
Xmax_cap564 _6618_/A VGND VGND VPWR VPWR _6586_/A sky130_fd_sc_hd__clkbuf_2
XFILLER_103_459 VGND VGND VPWR VPWR sky130_fd_sc_hd__decap_3
X_3467_ _7121_/Q _4351_/B1 _4352_/B1 _7153_/Q _3466_/X VGND VGND VPWR VPWR _3467_/X
+ sky130_fd_sc_hd__a221o_2
XFILLER_69_340 VGND VGND VPWR VPWR sky130_fd_sc_hd__fill_2
X_3398_ _4534_/S VGND VGND VPWR VPWR _3398_/Y sky130_fd_sc_hd__inv_2
XTAP_TAPCELL_ROW_4_303 VGND VPWR sky130_fd_sc_hd__tapvpwrvgnd_1
XFILLER_97_671 VGND VGND VPWR VPWR sky130_fd_sc_hd__fill_1
XFILLER_111_470 VGND VGND VPWR VPWR sky130_fd_sc_hd__decap_3
XFILLER_97_682 VGND VGND VPWR VPWR sky130_fd_sc_hd__decap_3
XFILLER_57_579 VGND VGND VPWR VPWR sky130_fd_sc_hd__decap_3
XFILLER_72_505 VGND VGND VPWR VPWR sky130_fd_sc_hd__decap_3
XFILLER_96_192 VGND VGND VPWR VPWR sky130_fd_sc_hd__fill_1
X_5068_ _6985_/Q _6986_/Q _5068_/C VGND VGND VPWR VPWR _5069_/B sky130_fd_sc_hd__and3_2
XFILLER_44_218 VGND VGND VPWR VPWR sky130_fd_sc_hd__decap_3
XFILLER_84_365 VGND VGND VPWR VPWR sky130_fd_sc_hd__fill_2
XFILLER_84_398 VGND VGND VPWR VPWR sky130_fd_sc_hd__fill_1
X_4019_ _7278_/Q _4401_/A2 _4430_/A2 _7246_/Q _4018_/X VGND VGND VPWR VPWR _4019_/X
+ sky130_fd_sc_hd__a221o_2
XFILLER_25_432 VGND VGND VPWR VPWR sky130_fd_sc_hd__decap_3
XFILLER_37_281 VGND VGND VPWR VPWR sky130_fd_sc_hd__decap_3
XFILLER_37_292 VGND VGND VPWR VPWR sky130_fd_sc_hd__decap_3
XFILLER_25_465 VGND VGND VPWR VPWR sky130_fd_sc_hd__decap_3
XFILLER_80_560 VGND VGND VPWR VPWR sky130_fd_sc_hd__decap_3
XTAP_TAPCELL_ROW_80_1208 VGND VPWR sky130_fd_sc_hd__tapvpwrvgnd_1
XPHY_EDGE_ROW_0_Right_0 VGND VGND VPWR VPWR sky130_fd_sc_hd__decap_3
XFILLER_13_638 VGND VGND VPWR VPWR sky130_fd_sc_hd__decap_3
XFILLER_40_457 VGND VGND VPWR VPWR sky130_fd_sc_hd__fill_1
XFILLER_9_609 VGND VGND VPWR VPWR sky130_fd_sc_hd__decap_3
XFILLER_21_671 VGND VGND VPWR VPWR sky130_fd_sc_hd__fill_1
XFILLER_21_682 VGND VGND VPWR VPWR sky130_fd_sc_hd__decap_3
XFILLER_20_192 VGND VGND VPWR VPWR sky130_fd_sc_hd__decap_3
XFILLER_106_297 VGND VGND VPWR VPWR sky130_fd_sc_hd__decap_3
XFILLER_79_148 VGND VGND VPWR VPWR sky130_fd_sc_hd__decap_3
XTAP_TAPCELL_ROW_91_1348 VGND VPWR sky130_fd_sc_hd__tapvpwrvgnd_1
XFILLER_88_660 VGND VGND VPWR VPWR sky130_fd_sc_hd__decap_3
XFILLER_0_575 VGND VGND VPWR VPWR sky130_fd_sc_hd__decap_3
XFILLER_87_181 VGND VGND VPWR VPWR sky130_fd_sc_hd__decap_3
XFILLER_102_492 VGND VGND VPWR VPWR sky130_fd_sc_hd__decap_3
XFILLER_48_579 VGND VGND VPWR VPWR sky130_fd_sc_hd__decap_3
XFILLER_35_207 VGND VGND VPWR VPWR sky130_fd_sc_hd__fill_2
XFILLER_28_281 VGND VGND VPWR VPWR sky130_fd_sc_hd__decap_3
XFILLER_90_335 VGND VGND VPWR VPWR sky130_fd_sc_hd__fill_1
XFILLER_16_443 VGND VGND VPWR VPWR sky130_fd_sc_hd__decap_3
XFILLER_43_251 VGND VGND VPWR VPWR sky130_fd_sc_hd__decap_3
XFILLER_43_284 VGND VGND VPWR VPWR sky130_fd_sc_hd__decap_3
XFILLER_71_582 VGND VGND VPWR VPWR sky130_fd_sc_hd__decap_3
XFILLER_12_660 VGND VGND VPWR VPWR sky130_fd_sc_hd__decap_3
XFILLER_31_479 VGND VGND VPWR VPWR sky130_fd_sc_hd__decap_3
XFILLER_8_631 VGND VGND VPWR VPWR sky130_fd_sc_hd__decap_3
XTAP_TAPCELL_ROW_100_1455 VGND VPWR sky130_fd_sc_hd__tapvpwrvgnd_1
XFILLER_7_130 VGND VGND VPWR VPWR sky130_fd_sc_hd__fill_2
XFILLER_8_675 VGND VGND VPWR VPWR sky130_fd_sc_hd__decap_3
X_4370_ _5100_/B _4361_/X _4362_/X _4369_/Y VGND VGND VPWR VPWR _5032_/B sky130_fd_sc_hd__a211o_2
X_3321_ _6981_/Q _6980_/Q VGND VGND VPWR VPWR _5294_/A sky130_fd_sc_hd__or2_4
XFILLER_98_413 VGND VGND VPWR VPWR sky130_fd_sc_hd__fill_2
XFILLER_112_245 VGND VGND VPWR VPWR sky130_fd_sc_hd__decap_3
XFILLER_112_256 VGND VGND VPWR VPWR sky130_fd_sc_hd__decap_3
XFILLER_86_619 VGND VGND VPWR VPWR sky130_fd_sc_hd__decap_3
XFILLER_100_418 VGND VGND VPWR VPWR sky130_fd_sc_hd__fill_2
XFILLER_39_513 VGND VGND VPWR VPWR sky130_fd_sc_hd__fill_1
XFILLER_39_535 VGND VGND VPWR VPWR sky130_fd_sc_hd__fill_2
XFILLER_66_321 VGND VGND VPWR VPWR sky130_fd_sc_hd__fill_1
XFILLER_79_671 VGND VGND VPWR VPWR sky130_fd_sc_hd__fill_1
XFILLER_79_682 VGND VGND VPWR VPWR sky130_fd_sc_hd__decap_3
XTAP_TAPCELL_ROW_111_1584 VGND VPWR sky130_fd_sc_hd__tapvpwrvgnd_1
XFILLER_66_332 VGND VGND VPWR VPWR sky130_fd_sc_hd__decap_3
XFILLER_94_663 VGND VGND VPWR VPWR sky130_fd_sc_hd__decap_3
XFILLER_39_579 VGND VGND VPWR VPWR sky130_fd_sc_hd__decap_3
XFILLER_66_365 VGND VGND VPWR VPWR sky130_fd_sc_hd__fill_1
XFILLER_81_302 VGND VGND VPWR VPWR sky130_fd_sc_hd__decap_3
XFILLER_19_270 VGND VGND VPWR VPWR sky130_fd_sc_hd__decap_3
XFILLER_19_281 VGND VGND VPWR VPWR sky130_fd_sc_hd__decap_3
XFILLER_81_335 VGND VGND VPWR VPWR sky130_fd_sc_hd__fill_1
X_6942_ _6943_/CLK _6942_/D VGND VGND VPWR VPWR _6942_/Q sky130_fd_sc_hd__dfxtp_2
XFILLER_62_560 VGND VGND VPWR VPWR sky130_fd_sc_hd__decap_3
XFILLER_81_368 VGND VGND VPWR VPWR sky130_fd_sc_hd__decap_3
X_6873_ _6954_/CLK _6873_/D VGND VGND VPWR VPWR _6873_/Q sky130_fd_sc_hd__dfxtp_2
XTAP_TAPCELL_ROW_66_1041 VGND VPWR sky130_fd_sc_hd__tapvpwrvgnd_1
XFILLER_22_413 VGND VGND VPWR VPWR sky130_fd_sc_hd__decap_3
XFILLER_34_273 VGND VGND VPWR VPWR sky130_fd_sc_hd__decap_3
XTAP_TAPCELL_ROW_45_791 VGND VPWR sky130_fd_sc_hd__tapvpwrvgnd_1
XTAP_TAPCELL_ROW_17_460 VGND VPWR sky130_fd_sc_hd__tapvpwrvgnd_1
XFILLER_10_619 VGND VGND VPWR VPWR sky130_fd_sc_hd__decap_3
XFILLER_108_507 VGND VGND VPWR VPWR sky130_fd_sc_hd__decap_3
X_5686_ _7349_/Q hold917/X _5703_/S VGND VGND VPWR VPWR _6693_/D sky130_fd_sc_hd__mux2_2
X_4706_ _6997_/Q _4931_/A VGND VGND VPWR VPWR _4912_/A sky130_fd_sc_hd__and2_2
X_4637_ _4380_/B _4637_/B _4637_/C VGND VGND VPWR VPWR _4950_/B sky130_fd_sc_hd__and3b_2
Xhold620 _6817_/Q VGND VGND VPWR VPWR _6817_/D sky130_fd_sc_hd__dlygate4sd3_1
XFILLER_89_402 VGND VGND VPWR VPWR sky130_fd_sc_hd__decap_3
X_7356_ _7392_/CLK _7356_/D _6636_/Y VGND VGND VPWR VPWR _7356_/Q sky130_fd_sc_hd__dfrtp_2
Xhold631 _6719_/Q VGND VGND VPWR VPWR _6719_/D sky130_fd_sc_hd__dlygate4sd3_1
Xhold642 _6926_/Q VGND VGND VPWR VPWR _6926_/D sky130_fd_sc_hd__dlygate4sd3_1
Xhold653 _6879_/Q VGND VGND VPWR VPWR _6879_/D sky130_fd_sc_hd__dlygate4sd3_1
XTAP_TAPCELL_ROW_77_1181 VGND VPWR sky130_fd_sc_hd__tapvpwrvgnd_1
XTAP_TAPCELL_ROW_77_1170 VGND VPWR sky130_fd_sc_hd__tapvpwrvgnd_1
XFILLER_116_595 VGND VGND VPWR VPWR sky130_fd_sc_hd__decap_3
X_7287_ _7317_/CLK _7287_/D _6567_/Y VGND VGND VPWR VPWR _7287_/Q sky130_fd_sc_hd__dfrtp_2
Xhold664 _6752_/Q VGND VGND VPWR VPWR _6752_/D sky130_fd_sc_hd__dlygate4sd3_1
Xhold675 _6940_/Q VGND VGND VPWR VPWR _6940_/D sky130_fd_sc_hd__dlygate4sd3_1
Xhold686 _6843_/Q VGND VGND VPWR VPWR _6843_/D sky130_fd_sc_hd__dlygate4sd3_1
Xhold697 _6767_/Q VGND VGND VPWR VPWR _6767_/D sky130_fd_sc_hd__dlygate4sd3_1
X_6307_ _6617_/A VGND VGND VPWR VPWR _6307_/Y sky130_fd_sc_hd__inv_2
X_4499_ _4499_/A0 _7298_/Q _4505_/S VGND VGND VPWR VPWR _7330_/D sky130_fd_sc_hd__mux2_2
X_3519_ _5129_/B _3519_/B VGND VGND VPWR VPWR _3519_/Y sky130_fd_sc_hd__nor2_2
XFILLER_103_256 VGND VGND VPWR VPWR sky130_fd_sc_hd__decap_3
XFILLER_103_267 VGND VGND VPWR VPWR sky130_fd_sc_hd__decap_3
XFILLER_76_129 VGND VGND VPWR VPWR sky130_fd_sc_hd__decap_3
XFILLER_27_11 VGND VGND VPWR VPWR sky130_fd_sc_hd__decap_3
XFILLER_85_641 VGND VGND VPWR VPWR sky130_fd_sc_hd__decap_3
XFILLER_45_505 VGND VGND VPWR VPWR sky130_fd_sc_hd__decap_3
XFILLER_85_685 VGND VGND VPWR VPWR sky130_fd_sc_hd__decap_3
XFILLER_27_55 VGND VGND VPWR VPWR sky130_fd_sc_hd__fill_1
XFILLER_25_240 VGND VGND VPWR VPWR sky130_fd_sc_hd__decap_3
XFILLER_25_251 VGND VGND VPWR VPWR sky130_fd_sc_hd__decap_3
XFILLER_25_284 VGND VGND VPWR VPWR sky130_fd_sc_hd__decap_3
XFILLER_53_582 VGND VGND VPWR VPWR sky130_fd_sc_hd__decap_3
XFILLER_40_221 VGND VGND VPWR VPWR sky130_fd_sc_hd__decap_3
XFILLER_80_390 VGND VGND VPWR VPWR sky130_fd_sc_hd__decap_3
XFILLER_40_265 VGND VGND VPWR VPWR sky130_fd_sc_hd__decap_3
Xclkbuf_leaf_20_clk clkload5/A VGND VGND VPWR VPWR _7144_/CLK sky130_fd_sc_hd__clkbuf_16
XFILLER_5_612 VGND VGND VPWR VPWR sky130_fd_sc_hd__decap_3
XFILLER_5_623 VGND VGND VPWR VPWR sky130_fd_sc_hd__decap_3
XFILLER_5_656 VGND VGND VPWR VPWR sky130_fd_sc_hd__decap_3
XFILLER_107_573 VGND VGND VPWR VPWR sky130_fd_sc_hd__decap_3
XFILLER_108_80 VGND VGND VPWR VPWR sky130_fd_sc_hd__fill_1
XFILLER_4_26 VGND VGND VPWR VPWR sky130_fd_sc_hd__fill_2
XFILLER_68_619 VGND VGND VPWR VPWR sky130_fd_sc_hd__decap_3
XFILLER_68_62 VGND VGND VPWR VPWR sky130_fd_sc_hd__decap_3
XFILLER_95_427 VGND VGND VPWR VPWR sky130_fd_sc_hd__fill_1
XFILLER_95_449 VGND VGND VPWR VPWR sky130_fd_sc_hd__decap_3
XFILLER_48_321 VGND VGND VPWR VPWR sky130_fd_sc_hd__decap_3
XFILLER_36_505 VGND VGND VPWR VPWR sky130_fd_sc_hd__decap_3
XFILLER_75_140 VGND VGND VPWR VPWR sky130_fd_sc_hd__decap_3
XFILLER_76_663 VGND VGND VPWR VPWR sky130_fd_sc_hd__decap_3
XFILLER_91_600 VGND VGND VPWR VPWR sky130_fd_sc_hd__decap_3
XFILLER_48_398 VGND VGND VPWR VPWR sky130_fd_sc_hd__fill_2
XFILLER_63_324 VGND VGND VPWR VPWR sky130_fd_sc_hd__decap_3
XFILLER_63_346 VGND VGND VPWR VPWR sky130_fd_sc_hd__decap_3
XFILLER_75_195 VGND VGND VPWR VPWR sky130_fd_sc_hd__decap_3
XFILLER_90_110 VGND VGND VPWR VPWR sky130_fd_sc_hd__decap_3
XFILLER_91_644 VGND VGND VPWR VPWR sky130_fd_sc_hd__decap_3
Xplace313 _5020_/A VGND VGND VPWR VPWR _4814_/A sky130_fd_sc_hd__buf_2
Xplace302 _3651_/Y VGND VGND VPWR VPWR _3879_/B1 sky130_fd_sc_hd__buf_2
XFILLER_16_240 VGND VGND VPWR VPWR sky130_fd_sc_hd__fill_2
XFILLER_44_560 VGND VGND VPWR VPWR sky130_fd_sc_hd__decap_3
XFILLER_91_688 VGND VGND VPWR VPWR sky130_fd_sc_hd__decap_3
Xplace346 _5114_/A VGND VGND VPWR VPWR _4970_/A1 sky130_fd_sc_hd__buf_2
Xplace335 _4267_/A2 VGND VGND VPWR VPWR _4434_/B1 sky130_fd_sc_hd__buf_2
Xplace324 _4422_/A2 VGND VGND VPWR VPWR _4401_/A2 sky130_fd_sc_hd__buf_2
XFILLER_16_262 VGND VGND VPWR VPWR sky130_fd_sc_hd__decap_3
Xplace379 _3874_/A VGND VGND VPWR VPWR _5104_/A sky130_fd_sc_hd__buf_2
Xplace368 _3577_/B VGND VGND VPWR VPWR _4305_/B sky130_fd_sc_hd__buf_2
Xplace357 _4823_/S VGND VGND VPWR VPWR _4946_/S sky130_fd_sc_hd__buf_2
X_3870_ _6760_/Q _3903_/A2 _3925_/A2 _6754_/Q _3869_/X VGND VGND VPWR VPWR _3870_/X
+ sky130_fd_sc_hd__a221o_2
XTAP_TAPCELL_ROW_42_761 VGND VPWR sky130_fd_sc_hd__tapvpwrvgnd_1
XTAP_TAPCELL_ROW_42_750 VGND VPWR sky130_fd_sc_hd__tapvpwrvgnd_1
XFILLER_76_3 VGND VGND VPWR VPWR sky130_fd_sc_hd__decap_3
Xclkbuf_leaf_11_clk clkbuf_leaf_9_clk/A VGND VGND VPWR VPWR _6941_/CLK sky130_fd_sc_hd__clkbuf_16
X_7210_ _7404_/CLK _7210_/D _6490_/Y VGND VGND VPWR VPWR _7210_/Q sky130_fd_sc_hd__dfrtp_2
X_4422_ _7272_/Q _4422_/A2 _4419_/X _4421_/X VGND VGND VPWR VPWR _4422_/X sky130_fd_sc_hd__a211o_2
XTAP_TAPCELL_ROW_113_1613 VGND VPWR sky130_fd_sc_hd__tapvpwrvgnd_1
XTAP_TAPCELL_ROW_113_1602 VGND VPWR sky130_fd_sc_hd__tapvpwrvgnd_1
XFILLER_113_532 VGND VGND VPWR VPWR sky130_fd_sc_hd__decap_3
X_7141_ _7368_/CLK _7141_/D _6421_/Y VGND VGND VPWR VPWR _7141_/Q sky130_fd_sc_hd__dfrtp_2
X_4353_ _7225_/Q _4414_/A2 _3975_/S _7193_/Q VGND VGND VPWR VPWR _4355_/A sky130_fd_sc_hd__a22o_2
XFILLER_98_221 VGND VGND VPWR VPWR sky130_fd_sc_hd__decap_3
X_7072_ _7362_/CLK _7072_/D _6352_/Y VGND VGND VPWR VPWR _7072_/Q sky130_fd_sc_hd__dfrtp_2
X_4284_ _7222_/Q _4284_/A2 _3987_/S _7190_/Q VGND VGND VPWR VPWR _4286_/A sky130_fd_sc_hd__a22o_2
X_3304_ _6982_/Q _6980_/Q VGND VGND VPWR VPWR _4696_/B sky130_fd_sc_hd__nand2_2
XFILLER_98_265 VGND VGND VPWR VPWR sky130_fd_sc_hd__decap_3
XFILLER_98_243 VGND VGND VPWR VPWR sky130_fd_sc_hd__decap_3
XFILLER_113_576 VGND VGND VPWR VPWR sky130_fd_sc_hd__decap_3
XFILLER_86_427 VGND VGND VPWR VPWR sky130_fd_sc_hd__decap_3
XFILLER_86_438 VGND VGND VPWR VPWR sky130_fd_sc_hd__decap_3
XFILLER_98_298 VGND VGND VPWR VPWR sky130_fd_sc_hd__decap_3
XFILLER_100_237 VGND VGND VPWR VPWR sky130_fd_sc_hd__decap_3
XFILLER_100_259 VGND VGND VPWR VPWR sky130_fd_sc_hd__decap_3
XFILLER_104_27 VGND VGND VPWR VPWR sky130_fd_sc_hd__fill_1
XFILLER_39_321 VGND VGND VPWR VPWR sky130_fd_sc_hd__decap_3
XFILLER_67_641 VGND VGND VPWR VPWR sky130_fd_sc_hd__decap_3
XFILLER_104_49 VGND VGND VPWR VPWR sky130_fd_sc_hd__decap_3
XFILLER_67_685 VGND VGND VPWR VPWR sky130_fd_sc_hd__decap_3
XFILLER_39_387 VGND VGND VPWR VPWR sky130_fd_sc_hd__decap_3
XFILLER_54_324 VGND VGND VPWR VPWR sky130_fd_sc_hd__decap_3
XFILLER_66_195 VGND VGND VPWR VPWR sky130_fd_sc_hd__fill_1
XFILLER_81_110 VGND VGND VPWR VPWR sky130_fd_sc_hd__fill_2
XFILLER_82_622 VGND VGND VPWR VPWR sky130_fd_sc_hd__decap_3
XFILLER_54_368 VGND VGND VPWR VPWR sky130_fd_sc_hd__decap_3
XFILLER_81_143 VGND VGND VPWR VPWR sky130_fd_sc_hd__decap_3
XFILLER_82_666 VGND VGND VPWR VPWR sky130_fd_sc_hd__decap_3
X_6925_ clkload7/A _6925_/D VGND VGND VPWR VPWR _6925_/Q sky130_fd_sc_hd__dfxtp_2
XFILLER_35_582 VGND VGND VPWR VPWR sky130_fd_sc_hd__decap_3
XFILLER_81_187 VGND VGND VPWR VPWR sky130_fd_sc_hd__decap_3
XFILLER_22_232 VGND VGND VPWR VPWR sky130_fd_sc_hd__decap_3
XFILLER_50_530 VGND VGND VPWR VPWR sky130_fd_sc_hd__fill_2
Xfanout25 fanout33/X VGND VGND VPWR VPWR _6630_/A sky130_fd_sc_hd__clkdlybuf4s25_1
Xfanout36 _6636_/A VGND VGND VPWR VPWR _6637_/A sky130_fd_sc_hd__buf_2
Xfanout47 reset VGND VGND VPWR VPWR fanout47/X sky130_fd_sc_hd__buf_1
X_6856_ _6966_/CLK _6856_/D VGND VGND VPWR VPWR _6856_/Q sky130_fd_sc_hd__dfxtp_2
XFILLER_22_276 VGND VGND VPWR VPWR sky130_fd_sc_hd__decap_3
XFILLER_50_563 VGND VGND VPWR VPWR sky130_fd_sc_hd__decap_3
Xfanout58 _6613_/A VGND VGND VPWR VPWR _6614_/A sky130_fd_sc_hd__buf_2
Xfanout69 _6288_/A VGND VGND VPWR VPWR wire569/A sky130_fd_sc_hd__buf_1
X_6787_ _6966_/CLK _6787_/D VGND VGND VPWR VPWR _6787_/Q sky130_fd_sc_hd__dfxtp_2
XFILLER_10_449 VGND VGND VPWR VPWR sky130_fd_sc_hd__decap_3
XFILLER_13_46 VGND VGND VPWR VPWR sky130_fd_sc_hd__fill_2
XFILLER_13_57 VGND VGND VPWR VPWR sky130_fd_sc_hd__decap_3
XFILLER_108_348 VGND VGND VPWR VPWR sky130_fd_sc_hd__fill_2
XTAP_TAPCELL_ROW_20_488 VGND VPWR sky130_fd_sc_hd__tapvpwrvgnd_1
XFILLER_2_604 VGND VGND VPWR VPWR sky130_fd_sc_hd__decap_3
XFILLER_104_510 VGND VGND VPWR VPWR sky130_fd_sc_hd__decap_3
XFILLER_2_637 VGND VGND VPWR VPWR sky130_fd_sc_hd__decap_3
XFILLER_2_648 VGND VGND VPWR VPWR sky130_fd_sc_hd__decap_3
XFILLER_89_210 VGND VGND VPWR VPWR sky130_fd_sc_hd__decap_3
X_7339_ _7405_/CLK _7339_/D _6619_/Y VGND VGND VPWR VPWR _7339_/Q sky130_fd_sc_hd__dfrtp_2
XFILLER_104_554 VGND VGND VPWR VPWR sky130_fd_sc_hd__decap_3
XFILLER_89_254 VGND VGND VPWR VPWR sky130_fd_sc_hd__fill_2
XPHY_EDGE_ROW_8_Left_125 VGND VGND VPWR VPWR sky130_fd_sc_hd__decap_3
XFILLER_104_587 VGND VGND VPWR VPWR sky130_fd_sc_hd__fill_1
XFILLER_104_598 VGND VGND VPWR VPWR sky130_fd_sc_hd__decap_3
XFILLER_77_427 VGND VGND VPWR VPWR sky130_fd_sc_hd__decap_3
XFILLER_89_287 VGND VGND VPWR VPWR sky130_fd_sc_hd__fill_1
XFILLER_77_449 VGND VGND VPWR VPWR sky130_fd_sc_hd__fill_1
XFILLER_58_663 VGND VGND VPWR VPWR sky130_fd_sc_hd__decap_3
XFILLER_73_600 VGND VGND VPWR VPWR sky130_fd_sc_hd__decap_3
Xhold1150 _7124_/Q VGND VGND VPWR VPWR _5419_/A0 sky130_fd_sc_hd__dlygate4sd3_1
XFILLER_45_335 VGND VGND VPWR VPWR sky130_fd_sc_hd__fill_1
XFILLER_57_184 VGND VGND VPWR VPWR sky130_fd_sc_hd__decap_3
XFILLER_73_644 VGND VGND VPWR VPWR sky130_fd_sc_hd__decap_3
XFILLER_85_482 VGND VGND VPWR VPWR sky130_fd_sc_hd__decap_3
Xhold1161 _7287_/Q VGND VGND VPWR VPWR _4587_/A sky130_fd_sc_hd__dlygate4sd3_1
Xhold1172 _7119_/Q VGND VGND VPWR VPWR _5429_/A0 sky130_fd_sc_hd__dlygate4sd3_1
Xhold1183 _7121_/Q VGND VGND VPWR VPWR _5425_/A0 sky130_fd_sc_hd__dlygate4sd3_1
Xhold1194 _7132_/Q VGND VGND VPWR VPWR _5402_/A0 sky130_fd_sc_hd__dlygate4sd3_1
XFILLER_73_688 VGND VGND VPWR VPWR sky130_fd_sc_hd__decap_3
XFILLER_26_571 VGND VGND VPWR VPWR sky130_fd_sc_hd__decap_3
XFILLER_60_327 VGND VGND VPWR VPWR sky130_fd_sc_hd__fill_2
XTAP_TAPCELL_ROW_28_588 VGND VPWR sky130_fd_sc_hd__tapvpwrvgnd_1
XFILLER_41_585 VGND VGND VPWR VPWR sky130_fd_sc_hd__decap_3
XFILLER_9_225 VGND VGND VPWR VPWR sky130_fd_sc_hd__decap_3
XFILLER_13_298 VGND VGND VPWR VPWR sky130_fd_sc_hd__fill_2
XFILLER_70_85 VGND VGND VPWR VPWR sky130_fd_sc_hd__fill_1
XFILLER_70_96 VGND VGND VPWR VPWR sky130_fd_sc_hd__decap_3
Xclkload17 _7353_/CLK VGND VGND VPWR VPWR clkload17/Y sky130_fd_sc_hd__bufinv_16
XFILLER_9_269 VGND VGND VPWR VPWR sky130_fd_sc_hd__decap_3
XFILLER_62_9 VGND VGND VPWR VPWR sky130_fd_sc_hd__decap_3
Xclkload28 _7406_/CLK VGND VGND VPWR VPWR clkload28/X sky130_fd_sc_hd__clkbuf_8
XFILLER_114_307 VGND VGND VPWR VPWR sky130_fd_sc_hd__fill_1
XFILLER_5_486 VGND VGND VPWR VPWR sky130_fd_sc_hd__fill_1
XFILLER_79_83 VGND VGND VPWR VPWR sky130_fd_sc_hd__decap_3
XFILLER_110_513 VGND VGND VPWR VPWR sky130_fd_sc_hd__decap_3
XFILLER_0_180 VGND VGND VPWR VPWR sky130_fd_sc_hd__decap_3
XFILLER_110_557 VGND VGND VPWR VPWR sky130_fd_sc_hd__decap_3
XFILLER_49_641 VGND VGND VPWR VPWR sky130_fd_sc_hd__decap_3
XFILLER_0_191 VGND VGND VPWR VPWR sky130_fd_sc_hd__decap_3
XFILLER_36_302 VGND VGND VPWR VPWR sky130_fd_sc_hd__decap_3
XFILLER_49_685 VGND VGND VPWR VPWR sky130_fd_sc_hd__decap_3
XFILLER_95_71 VGND VGND VPWR VPWR sky130_fd_sc_hd__decap_3
XFILLER_95_93 VGND VGND VPWR VPWR sky130_fd_sc_hd__decap_3
Xclkbuf_leaf_0_clk clkbuf_leaf_1_clk/A VGND VGND VPWR VPWR _6978_/CLK sky130_fd_sc_hd__clkbuf_16
XFILLER_64_622 VGND VGND VPWR VPWR sky130_fd_sc_hd__decap_3
XTAP_TAPCELL_ROW_47_820 VGND VPWR sky130_fd_sc_hd__tapvpwrvgnd_1
XFILLER_64_666 VGND VGND VPWR VPWR sky130_fd_sc_hd__decap_3
XFILLER_17_582 VGND VGND VPWR VPWR sky130_fd_sc_hd__decap_3
XFILLER_51_316 VGND VGND VPWR VPWR sky130_fd_sc_hd__decap_3
XFILLER_63_187 VGND VGND VPWR VPWR sky130_fd_sc_hd__decap_3
X_4971_ _4811_/C _4949_/Y _4967_/X _4969_/X _4970_/X VGND VGND VPWR VPWR _5661_/B
+ sky130_fd_sc_hd__a311oi_2
X_6710_ _6943_/CLK _6710_/D VGND VGND VPWR VPWR _6710_/Q sky130_fd_sc_hd__dfxtp_2
X_3922_ _6778_/Q _3922_/A2 _3922_/B1 _6866_/Q _3921_/X VGND VGND VPWR VPWR _3922_/X
+ sky130_fd_sc_hd__a221o_2
XTAP_TAPCELL_ROW_63_1011 VGND VPWR sky130_fd_sc_hd__tapvpwrvgnd_1
XFILLER_32_585 VGND VGND VPWR VPWR sky130_fd_sc_hd__decap_3
X_6641_ _6642_/A VGND VGND VPWR VPWR _6641_/Y sky130_fd_sc_hd__inv_2
X_3853_ _6736_/Q _3891_/A2 _3893_/B1 _6730_/Q _3852_/X VGND VGND VPWR VPWR _3853_/X
+ sky130_fd_sc_hd__a221o_2
X_6572_ _6608_/A VGND VGND VPWR VPWR _6572_/Y sky130_fd_sc_hd__inv_2
X_3784_ _6847_/Q _3892_/A2 _3852_/B1 _6842_/Q VGND VGND VPWR VPWR _3784_/X sky130_fd_sc_hd__a22o_2
XFILLER_8_280 VGND VGND VPWR VPWR sky130_fd_sc_hd__decap_3
Xoutput511 _5666_/A VGND VGND VPWR VPWR instruction_out[3] sky130_fd_sc_hd__clkdlybuf4s25_1
Xoutput500 _3421_/B VGND VGND VPWR VPWR instruction_out[20] sky130_fd_sc_hd__clkdlybuf4s25_1
Xoutput544 _3324_/A VGND VGND VPWR VPWR pc_out[4] sky130_fd_sc_hd__clkdlybuf4s25_1
Xoutput533 _7000_/Q VGND VGND VPWR VPWR pc_out[23] sky130_fd_sc_hd__clkdlybuf4s25_1
Xoutput522 _6990_/Q VGND VGND VPWR VPWR pc_out[13] sky130_fd_sc_hd__clkdlybuf4s25_1
X_4405_ _7242_/Q _4433_/B _3945_/S _7210_/Q VGND VGND VPWR VPWR _4405_/X sky130_fd_sc_hd__a22o_2
XFILLER_113_340 VGND VGND VPWR VPWR sky130_fd_sc_hd__decap_3
X_7124_ _7349_/CLK _7124_/D _6404_/Y VGND VGND VPWR VPWR _7124_/Q sky130_fd_sc_hd__dfrtp_2
X_4336_ _4336_/A _4336_/B _4336_/C VGND VGND VPWR VPWR _4336_/X sky130_fd_sc_hd__or3_2
XTAP_TAPCELL_ROW_74_1140 VGND VPWR sky130_fd_sc_hd__tapvpwrvgnd_1
XFILLER_99_541 VGND VGND VPWR VPWR sky130_fd_sc_hd__decap_3
XFILLER_113_384 VGND VGND VPWR VPWR sky130_fd_sc_hd__decap_3
XFILLER_115_15 VGND VGND VPWR VPWR sky130_fd_sc_hd__decap_3
XFILLER_59_427 VGND VGND VPWR VPWR sky130_fd_sc_hd__fill_1
XFILLER_59_438 VGND VGND VPWR VPWR sky130_fd_sc_hd__decap_3
XFILLER_86_213 VGND VGND VPWR VPWR sky130_fd_sc_hd__fill_2
XFILLER_99_585 VGND VGND VPWR VPWR sky130_fd_sc_hd__decap_3
XFILLER_101_535 VGND VGND VPWR VPWR sky130_fd_sc_hd__decap_3
XFILLER_115_48 VGND VGND VPWR VPWR sky130_fd_sc_hd__decap_3
XFILLER_59_449 VGND VGND VPWR VPWR sky130_fd_sc_hd__decap_3
X_7055_ _7311_/CLK _7055_/D _6335_/Y VGND VGND VPWR VPWR _7055_/Q sky130_fd_sc_hd__dfrtp_2
X_4267_ _7134_/Q _4267_/A2 _4267_/B1 _7166_/Q VGND VGND VPWR VPWR _4271_/B sky130_fd_sc_hd__a22o_2
XFILLER_101_579 VGND VGND VPWR VPWR sky130_fd_sc_hd__decap_3
XFILLER_27_302 VGND VGND VPWR VPWR sky130_fd_sc_hd__decap_3
XFILLER_55_600 VGND VGND VPWR VPWR sky130_fd_sc_hd__decap_3
XFILLER_74_419 VGND VGND VPWR VPWR sky130_fd_sc_hd__fill_1
X_4198_ _4194_/X _4197_/X _4327_/A VGND VGND VPWR VPWR _4380_/B sky130_fd_sc_hd__o21ai_2
XFILLER_27_335 VGND VGND VPWR VPWR sky130_fd_sc_hd__fill_1
XFILLER_55_644 VGND VGND VPWR VPWR sky130_fd_sc_hd__decap_3
XFILLER_82_430 VGND VGND VPWR VPWR sky130_fd_sc_hd__decap_3
XFILLER_27_379 VGND VGND VPWR VPWR sky130_fd_sc_hd__decap_3
XFILLER_55_688 VGND VGND VPWR VPWR sky130_fd_sc_hd__decap_3
XFILLER_70_625 VGND VGND VPWR VPWR sky130_fd_sc_hd__decap_3
XFILLER_70_669 VGND VGND VPWR VPWR sky130_fd_sc_hd__decap_3
X_6908_ _6959_/CLK _6908_/D VGND VGND VPWR VPWR _6908_/Q sky130_fd_sc_hd__dfxtp_2
XTAP_TAPCELL_ROW_25_547 VGND VPWR sky130_fd_sc_hd__tapvpwrvgnd_1
XFILLER_23_552 VGND VGND VPWR VPWR sky130_fd_sc_hd__decap_3
X_6839_ _6974_/CLK _6839_/D VGND VGND VPWR VPWR _6839_/Q sky130_fd_sc_hd__dfxtp_2
XTAP_TAPCELL_ROW_53_889 VGND VPWR sky130_fd_sc_hd__tapvpwrvgnd_1
XFILLER_10_224 VGND VGND VPWR VPWR sky130_fd_sc_hd__decap_3
XFILLER_23_585 VGND VGND VPWR VPWR sky130_fd_sc_hd__decap_3
XFILLER_50_371 VGND VGND VPWR VPWR sky130_fd_sc_hd__decap_3
XFILLER_6_217 VGND VGND VPWR VPWR sky130_fd_sc_hd__decap_3
XFILLER_109_635 VGND VGND VPWR VPWR sky130_fd_sc_hd__decap_3
XFILLER_109_668 VGND VGND VPWR VPWR sky130_fd_sc_hd__decap_3
XFILLER_109_679 VGND VGND VPWR VPWR sky130_fd_sc_hd__decap_3
XFILLER_40_99 VGND VGND VPWR VPWR sky130_fd_sc_hd__decap_3
XFILLER_2_445 VGND VGND VPWR VPWR sky130_fd_sc_hd__decap_3
XFILLER_6_3 VGND VGND VPWR VPWR sky130_fd_sc_hd__decap_3
XFILLER_2_467 VGND VGND VPWR VPWR sky130_fd_sc_hd__decap_3
XFILLER_2_489 VGND VGND VPWR VPWR sky130_fd_sc_hd__decap_3
XFILLER_77_213 VGND VGND VPWR VPWR sky130_fd_sc_hd__decap_3
XFILLER_65_408 VGND VGND VPWR VPWR sky130_fd_sc_hd__decap_3
XFILLER_77_268 VGND VGND VPWR VPWR sky130_fd_sc_hd__decap_3
XTAP_TAPCELL_ROW_88_1309 VGND VPWR sky130_fd_sc_hd__tapvpwrvgnd_1
XFILLER_18_324 VGND VGND VPWR VPWR sky130_fd_sc_hd__fill_2
XFILLER_46_622 VGND VGND VPWR VPWR sky130_fd_sc_hd__decap_3
XFILLER_92_227 VGND VGND VPWR VPWR sky130_fd_sc_hd__fill_2
XFILLER_18_368 VGND VGND VPWR VPWR sky130_fd_sc_hd__decap_3
XFILLER_46_666 VGND VGND VPWR VPWR sky130_fd_sc_hd__decap_3
XFILLER_61_603 VGND VGND VPWR VPWR sky130_fd_sc_hd__decap_3
XFILLER_85_290 VGND VGND VPWR VPWR sky130_fd_sc_hd__decap_3
XFILLER_33_305 VGND VGND VPWR VPWR sky130_fd_sc_hd__decap_3
XFILLER_45_187 VGND VGND VPWR VPWR sky130_fd_sc_hd__decap_3
XFILLER_73_474 VGND VGND VPWR VPWR sky130_fd_sc_hd__fill_2
XFILLER_61_647 VGND VGND VPWR VPWR sky130_fd_sc_hd__decap_3
XFILLER_14_563 VGND VGND VPWR VPWR sky130_fd_sc_hd__decap_3
XFILLER_41_382 VGND VGND VPWR VPWR sky130_fd_sc_hd__decap_3
XTAP_TAPCELL_ROW_99_1438 VGND VPWR sky130_fd_sc_hd__tapvpwrvgnd_1
XFILLER_108_690 VGND VGND VPWR VPWR sky130_fd_sc_hd__fill_1
XFILLER_114_115 VGND VGND VPWR VPWR sky130_fd_sc_hd__decap_3
XFILLER_114_126 VGND VGND VPWR VPWR sky130_fd_sc_hd__decap_3
XFILLER_115_638 VGND VGND VPWR VPWR sky130_fd_sc_hd__decap_3
XFILLER_114_159 VGND VGND VPWR VPWR sky130_fd_sc_hd__fill_1
XFILLER_39_3 VGND VGND VPWR VPWR sky130_fd_sc_hd__decap_3
XFILLER_96_500 VGND VGND VPWR VPWR sky130_fd_sc_hd__decap_3
XFILLER_68_224 VGND VGND VPWR VPWR sky130_fd_sc_hd__fill_2
XFILLER_96_533 VGND VGND VPWR VPWR sky130_fd_sc_hd__decap_3
X_4121_ _7140_/Q _4267_/A2 _4267_/B1 _7172_/Q _4120_/X VGND VGND VPWR VPWR _4121_/X
+ sky130_fd_sc_hd__a221o_2
XFILLER_110_365 VGND VGND VPWR VPWR sky130_fd_sc_hd__decap_3
XFILLER_37_600 VGND VGND VPWR VPWR sky130_fd_sc_hd__decap_3
XFILLER_56_419 VGND VGND VPWR VPWR sky130_fd_sc_hd__fill_1
XFILLER_96_566 VGND VGND VPWR VPWR sky130_fd_sc_hd__decap_3
X_4052_ _4047_/X _4050_/X _4425_/A VGND VGND VPWR VPWR _4456_/A sky130_fd_sc_hd__o21a_2
XFILLER_37_644 VGND VGND VPWR VPWR sky130_fd_sc_hd__decap_3
XTAP_TAPCELL_ROW_108_1545 VGND VPWR sky130_fd_sc_hd__tapvpwrvgnd_1
XFILLER_37_688 VGND VGND VPWR VPWR sky130_fd_sc_hd__decap_3
XFILLER_52_625 VGND VGND VPWR VPWR sky130_fd_sc_hd__decap_3
XFILLER_101_39 VGND VGND VPWR VPWR sky130_fd_sc_hd__decap_3
XFILLER_24_338 VGND VGND VPWR VPWR sky130_fd_sc_hd__decap_3
XFILLER_51_113 VGND VGND VPWR VPWR sky130_fd_sc_hd__fill_1
XFILLER_52_669 VGND VGND VPWR VPWR sky130_fd_sc_hd__decap_3
X_4954_ _4950_/A _4969_/C _4953_/Y _4200_/X VGND VGND VPWR VPWR _4954_/X sky130_fd_sc_hd__o211a_2
X_3905_ _3905_/A1 _5104_/A _3904_/Y VGND VGND VPWR VPWR _7380_/D sky130_fd_sc_hd__a21bo_2
XFILLER_20_533 VGND VGND VPWR VPWR sky130_fd_sc_hd__decap_3
X_4885_ _4904_/B _4903_/A VGND VGND VPWR VPWR _4886_/C sky130_fd_sc_hd__and2b_2
XTAP_TAPCELL_ROW_50_848 VGND VPWR sky130_fd_sc_hd__tapvpwrvgnd_1
XTAP_TAPCELL_ROW_22_517 VGND VPWR sky130_fd_sc_hd__tapvpwrvgnd_1
XFILLER_20_566 VGND VGND VPWR VPWR sky130_fd_sc_hd__decap_3
X_6624_ _6624_/A VGND VGND VPWR VPWR _6624_/Y sky130_fd_sc_hd__inv_2
X_3836_ _6970_/Q _3890_/B1 _3852_/B1 _6720_/Q _3835_/X VGND VGND VPWR VPWR _3836_/X
+ sky130_fd_sc_hd__a221o_2
X_6555_ _6557_/A VGND VGND VPWR VPWR _6555_/Y sky130_fd_sc_hd__inv_2
X_3767_ _6705_/Q _3925_/A2 _3922_/B1 _6883_/Q VGND VGND VPWR VPWR _3767_/X sky130_fd_sc_hd__a22o_2
XPHY_EDGE_ROW_89_Left_206 VGND VGND VPWR VPWR sky130_fd_sc_hd__decap_3
XFILLER_106_616 VGND VGND VPWR VPWR sky130_fd_sc_hd__decap_3
XFILLER_105_104 VGND VGND VPWR VPWR sky130_fd_sc_hd__decap_3
X_6486_ _6643_/A VGND VGND VPWR VPWR _6486_/Y sky130_fd_sc_hd__inv_2
X_3698_ _3698_/A1 _4832_/A _3697_/Y VGND VGND VPWR VPWR _7402_/D sky130_fd_sc_hd__o21ba_2
XFILLER_114_660 VGND VGND VPWR VPWR sky130_fd_sc_hd__decap_3
XFILLER_59_213 VGND VGND VPWR VPWR sky130_fd_sc_hd__decap_3
XFILLER_87_522 VGND VGND VPWR VPWR sky130_fd_sc_hd__decap_3
XFILLER_87_555 VGND VGND VPWR VPWR sky130_fd_sc_hd__decap_3
X_7107_ _7365_/CLK _7107_/D _6387_/Y VGND VGND VPWR VPWR _7107_/Q sky130_fd_sc_hd__dfrtp_2
X_4319_ _7258_/Q _4356_/A2 _4316_/X _4318_/X VGND VGND VPWR VPWR _4362_/A sky130_fd_sc_hd__a211o_2
XFILLER_99_393 VGND VGND VPWR VPWR sky130_fd_sc_hd__decap_3
XFILLER_99_382 VGND VGND VPWR VPWR sky130_fd_sc_hd__fill_1
XFILLER_101_343 VGND VGND VPWR VPWR sky130_fd_sc_hd__decap_3
XFILLER_47_419 VGND VGND VPWR VPWR sky130_fd_sc_hd__decap_3
XFILLER_59_257 VGND VGND VPWR VPWR sky130_fd_sc_hd__fill_1
XFILLER_59_268 VGND VGND VPWR VPWR sky130_fd_sc_hd__decap_3
XFILLER_87_588 VGND VGND VPWR VPWR sky130_fd_sc_hd__decap_3
X_7038_ _7398_/CLK _7038_/D _6318_/Y VGND VGND VPWR VPWR _7038_/Q sky130_fd_sc_hd__dfrtp_2
XPHY_EDGE_ROW_98_Left_215 VGND VGND VPWR VPWR sky130_fd_sc_hd__decap_3
XFILLER_27_110 VGND VGND VPWR VPWR sky130_fd_sc_hd__fill_2
XFILLER_28_622 VGND VGND VPWR VPWR sky130_fd_sc_hd__decap_3
XFILLER_74_227 VGND VGND VPWR VPWR sky130_fd_sc_hd__decap_3
XFILLER_74_238 VGND VGND VPWR VPWR sky130_fd_sc_hd__decap_3
XTAP_TAPCELL_ROW_58_948 VGND VPWR sky130_fd_sc_hd__tapvpwrvgnd_1
XFILLER_27_143 VGND VGND VPWR VPWR sky130_fd_sc_hd__decap_3
XFILLER_28_666 VGND VGND VPWR VPWR sky130_fd_sc_hd__decap_3
XFILLER_55_430 VGND VGND VPWR VPWR sky130_fd_sc_hd__decap_3
XFILLER_55_452 VGND VGND VPWR VPWR sky130_fd_sc_hd__decap_3
XFILLER_67_290 VGND VGND VPWR VPWR sky130_fd_sc_hd__decap_3
XFILLER_27_165 VGND VGND VPWR VPWR sky130_fd_sc_hd__decap_3
XFILLER_43_603 VGND VGND VPWR VPWR sky130_fd_sc_hd__decap_3
XFILLER_70_411 VGND VGND VPWR VPWR sky130_fd_sc_hd__fill_1
XTAP_TAPCELL_ROW_2_275 VGND VPWR sky130_fd_sc_hd__tapvpwrvgnd_1
XFILLER_43_647 VGND VGND VPWR VPWR sky130_fd_sc_hd__decap_3
XFILLER_42_146 VGND VGND VPWR VPWR sky130_fd_sc_hd__fill_1
XFILLER_70_477 VGND VGND VPWR VPWR sky130_fd_sc_hd__decap_3
XFILLER_23_371 VGND VGND VPWR VPWR sky130_fd_sc_hd__decap_3
XFILLER_23_393 VGND VGND VPWR VPWR sky130_fd_sc_hd__decap_3
XFILLER_11_544 VGND VGND VPWR VPWR sky130_fd_sc_hd__decap_3
XFILLER_109_432 VGND VGND VPWR VPWR sky130_fd_sc_hd__decap_3
XFILLER_11_588 VGND VGND VPWR VPWR sky130_fd_sc_hd__decap_3
XFILLER_7_526 VGND VGND VPWR VPWR sky130_fd_sc_hd__decap_3
XFILLER_7_559 VGND VGND VPWR VPWR sky130_fd_sc_hd__fill_1
XFILLER_109_476 VGND VGND VPWR VPWR sky130_fd_sc_hd__decap_3
XFILLER_2_220 VGND VGND VPWR VPWR sky130_fd_sc_hd__decap_3
XTAP_TAPCELL_ROW_94_1379 VGND VPWR sky130_fd_sc_hd__tapvpwrvgnd_1
XFILLER_105_671 VGND VGND VPWR VPWR sky130_fd_sc_hd__fill_1
XFILLER_105_682 VGND VGND VPWR VPWR sky130_fd_sc_hd__decap_3
XFILLER_112_619 VGND VGND VPWR VPWR sky130_fd_sc_hd__decap_3
XFILLER_2_242 VGND VGND VPWR VPWR sky130_fd_sc_hd__decap_3
XFILLER_2_253 VGND VGND VPWR VPWR sky130_fd_sc_hd__decap_3
XFILLER_97_319 VGND VGND VPWR VPWR sky130_fd_sc_hd__decap_3
XFILLER_2_275 VGND VGND VPWR VPWR sky130_fd_sc_hd__decap_3
XFILLER_78_533 VGND VGND VPWR VPWR sky130_fd_sc_hd__decap_3
XFILLER_116_91 VGND VGND VPWR VPWR sky130_fd_sc_hd__decap_3
XFILLER_19_600 VGND VGND VPWR VPWR sky130_fd_sc_hd__decap_3
XFILLER_78_566 VGND VGND VPWR VPWR sky130_fd_sc_hd__decap_3
XFILLER_93_514 VGND VGND VPWR VPWR sky130_fd_sc_hd__decap_3
XFILLER_76_73 VGND VGND VPWR VPWR sky130_fd_sc_hd__decap_3
XFILLER_93_547 VGND VGND VPWR VPWR sky130_fd_sc_hd__decap_3
XFILLER_18_110 VGND VGND VPWR VPWR sky130_fd_sc_hd__decap_3
XFILLER_19_644 VGND VGND VPWR VPWR sky130_fd_sc_hd__decap_3
XFILLER_76_95 VGND VGND VPWR VPWR sky130_fd_sc_hd__decap_3
XFILLER_19_688 VGND VGND VPWR VPWR sky130_fd_sc_hd__decap_3
XFILLER_34_625 VGND VGND VPWR VPWR sky130_fd_sc_hd__decap_3
XFILLER_80_208 VGND VGND VPWR VPWR sky130_fd_sc_hd__decap_3
XFILLER_34_669 VGND VGND VPWR VPWR sky130_fd_sc_hd__decap_3
XFILLER_73_293 VGND VGND VPWR VPWR sky130_fd_sc_hd__decap_3
XFILLER_33_179 VGND VGND VPWR VPWR sky130_fd_sc_hd__fill_1
XFILLER_61_455 VGND VGND VPWR VPWR sky130_fd_sc_hd__decap_3
XTAP_TAPCELL_ROW_103_1486 VGND VPWR sky130_fd_sc_hd__tapvpwrvgnd_1
X_4670_ _6995_/Q _5633_/B VGND VGND VPWR VPWR _4682_/B sky130_fd_sc_hd__or2_2
X_3621_ _3621_/A _3621_/B VGND VGND VPWR VPWR _4852_/A sky130_fd_sc_hd__nand2_2
X_6340_ _6629_/A VGND VGND VPWR VPWR _6340_/Y sky130_fd_sc_hd__inv_2
X_3552_ _3508_/Y _5020_/A _3620_/A _3537_/X _3551_/X VGND VGND VPWR VPWR _3746_/A
+ sky130_fd_sc_hd__o311a_2
XFILLER_115_402 VGND VGND VPWR VPWR sky130_fd_sc_hd__decap_3
XFILLER_6_581 VGND VGND VPWR VPWR sky130_fd_sc_hd__decap_3
XFILLER_115_435 VGND VGND VPWR VPWR sky130_fd_sc_hd__decap_3
XFILLER_6_592 VGND VGND VPWR VPWR sky130_fd_sc_hd__decap_3
X_6271_ _6278_/A VGND VGND VPWR VPWR _6271_/Y sky130_fd_sc_hd__inv_2
X_3483_ _3874_/A _3442_/B _3409_/D VGND VGND VPWR VPWR _5153_/B sky130_fd_sc_hd__a21o_2
XFILLER_102_118 VGND VGND VPWR VPWR sky130_fd_sc_hd__decap_3
XFILLER_115_479 VGND VGND VPWR VPWR sky130_fd_sc_hd__decap_3
XFILLER_69_544 VGND VGND VPWR VPWR sky130_fd_sc_hd__decap_3
X_5153_ _7010_/D _5153_/B VGND VGND VPWR VPWR _5153_/X sky130_fd_sc_hd__xor2_2
XFILLER_111_641 VGND VGND VPWR VPWR sky130_fd_sc_hd__decap_3
XFILLER_69_588 VGND VGND VPWR VPWR sky130_fd_sc_hd__decap_3
XFILLER_96_341 VGND VGND VPWR VPWR sky130_fd_sc_hd__fill_2
X_4104_ _7237_/Q _4433_/B _4269_/B1 _7050_/Q VGND VGND VPWR VPWR _4104_/X sky130_fd_sc_hd__a22o_2
XFILLER_111_685 VGND VGND VPWR VPWR sky130_fd_sc_hd__decap_3
XFILLER_84_536 VGND VGND VPWR VPWR sky130_fd_sc_hd__decap_3
X_5084_ _4343_/X _5084_/B _5086_/A VGND VGND VPWR VPWR _5084_/X sky130_fd_sc_hd__and3b_2
XFILLER_84_569 VGND VGND VPWR VPWR sky130_fd_sc_hd__decap_3
X_4035_ _7374_/Q _4093_/B _4436_/B1 _7182_/Q _4034_/X VGND VGND VPWR VPWR _4035_/X
+ sky130_fd_sc_hd__a221o_2
XTAP_TAPCELL_ROW_55_907 VGND VPWR sky130_fd_sc_hd__tapvpwrvgnd_1
XFILLER_112_27 VGND VGND VPWR VPWR sky130_fd_sc_hd__fill_1
XFILLER_112_38 VGND VGND VPWR VPWR sky130_fd_sc_hd__decap_3
XFILLER_25_603 VGND VGND VPWR VPWR sky130_fd_sc_hd__decap_3
XFILLER_37_463 VGND VGND VPWR VPWR sky130_fd_sc_hd__decap_3
XFILLER_24_113 VGND VGND VPWR VPWR sky130_fd_sc_hd__decap_3
XFILLER_25_647 VGND VGND VPWR VPWR sky130_fd_sc_hd__decap_3
XFILLER_52_433 VGND VGND VPWR VPWR sky130_fd_sc_hd__decap_3
XFILLER_64_271 VGND VGND VPWR VPWR sky130_fd_sc_hd__decap_3
XTAP_TAPCELL_ROW_69_1083 VGND VPWR sky130_fd_sc_hd__tapvpwrvgnd_1
XFILLER_24_168 VGND VGND VPWR VPWR sky130_fd_sc_hd__decap_3
XFILLER_52_477 VGND VGND VPWR VPWR sky130_fd_sc_hd__decap_3
XFILLER_40_628 VGND VGND VPWR VPWR sky130_fd_sc_hd__decap_3
X_4937_ _4937_/A _4937_/B VGND VGND VPWR VPWR _4937_/Y sky130_fd_sc_hd__xnor2_2
XTAP_TAPCELL_ROW_35_675 VGND VPWR sky130_fd_sc_hd__tapvpwrvgnd_1
X_4868_ _6999_/Q _4882_/A VGND VGND VPWR VPWR _6999_/D sky130_fd_sc_hd__xnor2_2
X_6607_ _6612_/A VGND VGND VPWR VPWR _6607_/Y sky130_fd_sc_hd__inv_2
X_3819_ _6791_/Q _3903_/A2 _3922_/B1 _6879_/Q VGND VGND VPWR VPWR _3819_/X sky130_fd_sc_hd__a22o_2
XFILLER_20_385 VGND VGND VPWR VPWR sky130_fd_sc_hd__decap_3
XFILLER_4_507 VGND VGND VPWR VPWR sky130_fd_sc_hd__decap_3
X_4799_ _4799_/A _5656_/A VGND VGND VPWR VPWR _4799_/X sky130_fd_sc_hd__or2_2
XFILLER_21_57 VGND VGND VPWR VPWR sky130_fd_sc_hd__fill_1
X_6538_ _6633_/A VGND VGND VPWR VPWR _6538_/Y sky130_fd_sc_hd__inv_2
XFILLER_106_457 VGND VGND VPWR VPWR sky130_fd_sc_hd__decap_3
XFILLER_108_6 VGND VGND VPWR VPWR sky130_fd_sc_hd__decap_3
X_6469_ _6663_/A VGND VGND VPWR VPWR _6469_/Y sky130_fd_sc_hd__inv_2
XTAP_TAPCELL_ROW_7_334 VGND VPWR sky130_fd_sc_hd__tapvpwrvgnd_1
XFILLER_101_140 VGND VGND VPWR VPWR sky130_fd_sc_hd__decap_3
XFILLER_102_663 VGND VGND VPWR VPWR sky130_fd_sc_hd__decap_3
XFILLER_87_363 VGND VGND VPWR VPWR sky130_fd_sc_hd__decap_3
XPHY_EDGE_ROW_102_Right_102 VGND VGND VPWR VPWR sky130_fd_sc_hd__decap_3
XFILLER_75_547 VGND VGND VPWR VPWR sky130_fd_sc_hd__decap_3
XFILLER_16_625 VGND VGND VPWR VPWR sky130_fd_sc_hd__decap_3
XFILLER_28_474 VGND VGND VPWR VPWR sky130_fd_sc_hd__fill_2
XFILLER_43_400 VGND VGND VPWR VPWR sky130_fd_sc_hd__fill_2
XFILLER_90_539 VGND VGND VPWR VPWR sky130_fd_sc_hd__decap_3
XFILLER_55_293 VGND VGND VPWR VPWR sky130_fd_sc_hd__decap_3
XFILLER_83_591 VGND VGND VPWR VPWR sky130_fd_sc_hd__decap_3
XFILLER_16_669 VGND VGND VPWR VPWR sky130_fd_sc_hd__decap_3
XFILLER_31_606 VGND VGND VPWR VPWR sky130_fd_sc_hd__decap_3
XFILLER_31_617 VGND VGND VPWR VPWR sky130_fd_sc_hd__decap_3
XFILLER_43_477 VGND VGND VPWR VPWR sky130_fd_sc_hd__decap_3
XFILLER_70_296 VGND VGND VPWR VPWR sky130_fd_sc_hd__decap_3
XFILLER_30_149 VGND VGND VPWR VPWR sky130_fd_sc_hd__fill_1
XTAP_TAPCELL_ROW_96_1408 VGND VPWR sky130_fd_sc_hd__tapvpwrvgnd_1
XFILLER_11_396 VGND VGND VPWR VPWR sky130_fd_sc_hd__decap_3
XFILLER_109_284 VGND VGND VPWR VPWR sky130_fd_sc_hd__decap_3
XFILLER_7_389 VGND VGND VPWR VPWR sky130_fd_sc_hd__decap_3
XFILLER_109_295 VGND VGND VPWR VPWR sky130_fd_sc_hd__decap_3
XFILLER_3_573 VGND VGND VPWR VPWR sky130_fd_sc_hd__decap_3
XFILLER_98_628 VGND VGND VPWR VPWR sky130_fd_sc_hd__decap_3
XFILLER_112_427 VGND VGND VPWR VPWR sky130_fd_sc_hd__decap_3
XFILLER_97_138 VGND VGND VPWR VPWR sky130_fd_sc_hd__decap_3
XFILLER_66_503 VGND VGND VPWR VPWR sky130_fd_sc_hd__fill_2
XFILLER_66_514 VGND VGND VPWR VPWR sky130_fd_sc_hd__decap_3
XFILLER_19_430 VGND VGND VPWR VPWR sky130_fd_sc_hd__decap_3
XFILLER_38_238 VGND VGND VPWR VPWR sky130_fd_sc_hd__decap_3
XFILLER_66_569 VGND VGND VPWR VPWR sky130_fd_sc_hd__decap_3
XFILLER_19_452 VGND VGND VPWR VPWR sky130_fd_sc_hd__decap_3
XFILLER_53_219 VGND VGND VPWR VPWR sky130_fd_sc_hd__decap_3
XFILLER_81_539 VGND VGND VPWR VPWR sky130_fd_sc_hd__decap_3
XFILLER_19_485 VGND VGND VPWR VPWR sky130_fd_sc_hd__decap_3
XFILLER_46_293 VGND VGND VPWR VPWR sky130_fd_sc_hd__fill_1
XFILLER_93_399 VGND VGND VPWR VPWR sky130_fd_sc_hd__decap_3
XTAP_TAPCELL_ROW_105_1515 VGND VPWR sky130_fd_sc_hd__tapvpwrvgnd_1
XFILLER_34_466 VGND VGND VPWR VPWR sky130_fd_sc_hd__decap_3
XFILLER_34_477 VGND VGND VPWR VPWR sky130_fd_sc_hd__decap_3
XFILLER_21_116 VGND VGND VPWR VPWR sky130_fd_sc_hd__fill_1
XFILLER_22_628 VGND VGND VPWR VPWR sky130_fd_sc_hd__decap_3
XFILLER_61_263 VGND VGND VPWR VPWR sky130_fd_sc_hd__decap_3
XFILLER_61_296 VGND VGND VPWR VPWR sky130_fd_sc_hd__decap_3
XFILLER_14_190 VGND VGND VPWR VPWR sky130_fd_sc_hd__fill_2
XTAP_TAPCELL_ROW_32_634 VGND VPWR sky130_fd_sc_hd__tapvpwrvgnd_1
XFILLER_30_672 VGND VGND VPWR VPWR sky130_fd_sc_hd__decap_3
XTAP_TAPCELL_ROW_60_976 VGND VPWR sky130_fd_sc_hd__tapvpwrvgnd_1
X_4653_ _4648_/Y _4785_/A _4413_/A _4397_/A VGND VGND VPWR VPWR _4653_/Y sky130_fd_sc_hd__a211oi_2
X_7372_ _7372_/CLK _7372_/D _6652_/Y VGND VGND VPWR VPWR _7372_/Q sky130_fd_sc_hd__dfrtp_2
Xhold802 _6774_/Q VGND VGND VPWR VPWR _6774_/D sky130_fd_sc_hd__dlygate4sd3_1
X_3604_ _4938_/A _3609_/B VGND VGND VPWR VPWR _3621_/B sky130_fd_sc_hd__nor2_2
XTAP_TAPCELL_ROW_12_391 VGND VPWR sky130_fd_sc_hd__tapvpwrvgnd_1
Xhold813 _6866_/Q VGND VGND VPWR VPWR _6866_/D sky130_fd_sc_hd__dlygate4sd3_1
Xhold824 _6818_/Q VGND VGND VPWR VPWR _6818_/D sky130_fd_sc_hd__dlygate4sd3_1
Xhold835 _6769_/Q VGND VGND VPWR VPWR _6769_/D sky130_fd_sc_hd__dlygate4sd3_1
Xhold846 _7065_/Q VGND VGND VPWR VPWR _7065_/D sky130_fd_sc_hd__dlygate4sd3_1
Xmax_cap554 _5047_/Y VGND VGND VPWR VPWR _5084_/B sky130_fd_sc_hd__clkdlybuf4s25_1
X_6323_ _6642_/A VGND VGND VPWR VPWR _6323_/Y sky130_fd_sc_hd__inv_2
X_3535_ _3621_/A _5071_/A _4764_/B VGND VGND VPWR VPWR _3536_/B sky130_fd_sc_hd__and3_2
XTAP_TAPCELL_ROW_116_1655 VGND VPWR sky130_fd_sc_hd__tapvpwrvgnd_1
XTAP_TAPCELL_ROW_116_1644 VGND VPWR sky130_fd_sc_hd__tapvpwrvgnd_1
XFILLER_107_27 VGND VGND VPWR VPWR sky130_fd_sc_hd__decap_3
XFILLER_89_606 VGND VGND VPWR VPWR sky130_fd_sc_hd__decap_3
XFILLER_89_617 VGND VGND VPWR VPWR sky130_fd_sc_hd__decap_3
Xhold857 _7073_/Q VGND VGND VPWR VPWR _7073_/D sky130_fd_sc_hd__dlygate4sd3_1
Xhold868 _7105_/Q VGND VGND VPWR VPWR _7105_/D sky130_fd_sc_hd__dlygate4sd3_1
Xhold879 _7081_/Q VGND VGND VPWR VPWR _7081_/D sky130_fd_sc_hd__dlygate4sd3_1
Xmax_cap576 fanout47/X VGND VGND VPWR VPWR fanout38/A sky130_fd_sc_hd__buf_2
Xmax_cap565 _6616_/A VGND VGND VPWR VPWR _6618_/A sky130_fd_sc_hd__clkbuf_2
X_3466_ _7217_/Q _4284_/A2 _4300_/B _7030_/Q _3465_/X VGND VGND VPWR VPWR _3466_/X
+ sky130_fd_sc_hd__a221o_2
XFILLER_103_438 VGND VGND VPWR VPWR sky130_fd_sc_hd__fill_2
XFILLER_88_127 VGND VGND VPWR VPWR sky130_fd_sc_hd__decap_3
X_5205_ _5205_/A _5209_/B VGND VGND VPWR VPWR _7226_/D sky130_fd_sc_hd__and2_2
XFILLER_57_503 VGND VGND VPWR VPWR sky130_fd_sc_hd__fill_1
XFILLER_69_352 VGND VGND VPWR VPWR sky130_fd_sc_hd__fill_2
XFILLER_69_363 VGND VGND VPWR VPWR sky130_fd_sc_hd__decap_3
XTAP_TAPCELL_ROW_4_304 VGND VPWR sky130_fd_sc_hd__tapvpwrvgnd_1
XFILLER_97_650 VGND VGND VPWR VPWR sky130_fd_sc_hd__decap_3
XFILLER_111_482 VGND VGND VPWR VPWR sky130_fd_sc_hd__decap_3
XFILLER_57_525 VGND VGND VPWR VPWR sky130_fd_sc_hd__decap_3
XFILLER_57_536 VGND VGND VPWR VPWR sky130_fd_sc_hd__decap_3
XFILLER_69_396 VGND VGND VPWR VPWR sky130_fd_sc_hd__fill_1
XFILLER_96_171 VGND VGND VPWR VPWR sky130_fd_sc_hd__decap_3
X_5136_ _5136_/A0 _5135_/X _5159_/S VGND VGND VPWR VPWR _7251_/D sky130_fd_sc_hd__mux2_2
XFILLER_29_249 VGND VGND VPWR VPWR sky130_fd_sc_hd__decap_3
X_5067_ _5648_/A _5067_/B VGND VGND VPWR VPWR _5068_/C sky130_fd_sc_hd__or2_2
X_4018_ _7150_/Q _4428_/B1 _4011_/X _4017_/X VGND VGND VPWR VPWR _4018_/X sky130_fd_sc_hd__a211o_2
XFILLER_37_271 VGND VGND VPWR VPWR sky130_fd_sc_hd__fill_1
XFILLER_65_591 VGND VGND VPWR VPWR sky130_fd_sc_hd__decap_3
XFILLER_13_606 VGND VGND VPWR VPWR sky130_fd_sc_hd__decap_3
XFILLER_13_617 VGND VGND VPWR VPWR sky130_fd_sc_hd__decap_3
XFILLER_25_455 VGND VGND VPWR VPWR sky130_fd_sc_hd__fill_1
XFILLER_52_241 VGND VGND VPWR VPWR sky130_fd_sc_hd__decap_3
XTAP_TAPCELL_ROW_80_1209 VGND VPWR sky130_fd_sc_hd__tapvpwrvgnd_1
XFILLER_52_285 VGND VGND VPWR VPWR sky130_fd_sc_hd__decap_3
XFILLER_80_572 VGND VGND VPWR VPWR sky130_fd_sc_hd__decap_3
XFILLER_21_650 VGND VGND VPWR VPWR sky130_fd_sc_hd__decap_3
XFILLER_20_160 VGND VGND VPWR VPWR sky130_fd_sc_hd__decap_3
XFILLER_4_315 VGND VGND VPWR VPWR sky130_fd_sc_hd__decap_3
XTAP_TAPCELL_ROW_91_1338 VGND VPWR sky130_fd_sc_hd__tapvpwrvgnd_1
XFILLER_0_521 VGND VGND VPWR VPWR sky130_fd_sc_hd__decap_3
XTAP_TAPCELL_ROW_91_1349 VGND VPWR sky130_fd_sc_hd__tapvpwrvgnd_1
XFILLER_0_543 VGND VGND VPWR VPWR sky130_fd_sc_hd__decap_3
XFILLER_95_609 VGND VGND VPWR VPWR sky130_fd_sc_hd__decap_3
XFILLER_0_587 VGND VGND VPWR VPWR sky130_fd_sc_hd__fill_1
XFILLER_0_598 VGND VGND VPWR VPWR sky130_fd_sc_hd__decap_3
XFILLER_102_471 VGND VGND VPWR VPWR sky130_fd_sc_hd__decap_3
XFILLER_57_42 VGND VGND VPWR VPWR sky130_fd_sc_hd__decap_3
XFILLER_88_672 VGND VGND VPWR VPWR sky130_fd_sc_hd__decap_3
XFILLER_75_344 VGND VGND VPWR VPWR sky130_fd_sc_hd__decap_3
XFILLER_113_81 VGND VGND VPWR VPWR sky130_fd_sc_hd__decap_3
XFILLER_63_539 VGND VGND VPWR VPWR sky130_fd_sc_hd__decap_3
XFILLER_71_561 VGND VGND VPWR VPWR sky130_fd_sc_hd__decap_3
XFILLER_16_477 VGND VGND VPWR VPWR sky130_fd_sc_hd__decap_3
XFILLER_71_594 VGND VGND VPWR VPWR sky130_fd_sc_hd__decap_3
XFILLER_73_85 VGND VGND VPWR VPWR sky130_fd_sc_hd__fill_1
XFILLER_31_436 VGND VGND VPWR VPWR sky130_fd_sc_hd__decap_3
XFILLER_31_458 VGND VGND VPWR VPWR sky130_fd_sc_hd__decap_3
XFILLER_12_672 VGND VGND VPWR VPWR sky130_fd_sc_hd__decap_3
XFILLER_8_610 VGND VGND VPWR VPWR sky130_fd_sc_hd__decap_3
XTAP_TAPCELL_ROW_100_1456 VGND VPWR sky130_fd_sc_hd__tapvpwrvgnd_1
XFILLER_8_643 VGND VGND VPWR VPWR sky130_fd_sc_hd__fill_1
XFILLER_8_654 VGND VGND VPWR VPWR sky130_fd_sc_hd__decap_3
XFILLER_8_687 VGND VGND VPWR VPWR sky130_fd_sc_hd__decap_3
X_3320_ _5647_/B VGND VGND VPWR VPWR _3326_/A sky130_fd_sc_hd__inv_2
XFILLER_98_71 VGND VGND VPWR VPWR sky130_fd_sc_hd__decap_3
XFILLER_112_224 VGND VGND VPWR VPWR sky130_fd_sc_hd__decap_3
XFILLER_112_268 VGND VGND VPWR VPWR sky130_fd_sc_hd__decap_3
XFILLER_79_650 VGND VGND VPWR VPWR sky130_fd_sc_hd__decap_3
XFILLER_78_171 VGND VGND VPWR VPWR sky130_fd_sc_hd__decap_3
XFILLER_85_119 VGND VGND VPWR VPWR sky130_fd_sc_hd__decap_3
XTAP_TAPCELL_ROW_111_1585 VGND VPWR sky130_fd_sc_hd__tapvpwrvgnd_1
XFILLER_39_558 VGND VGND VPWR VPWR sky130_fd_sc_hd__fill_2
XFILLER_94_631 VGND VGND VPWR VPWR sky130_fd_sc_hd__decap_3
XFILLER_94_675 VGND VGND VPWR VPWR sky130_fd_sc_hd__decap_3
XFILLER_47_591 VGND VGND VPWR VPWR sky130_fd_sc_hd__decap_3
XFILLER_93_196 VGND VGND VPWR VPWR sky130_fd_sc_hd__decap_3
X_6941_ _6941_/CLK _6941_/D VGND VGND VPWR VPWR _6941_/Q sky130_fd_sc_hd__dfxtp_2
X_6872_ clkload8/A _6872_/D VGND VGND VPWR VPWR _6872_/Q sky130_fd_sc_hd__dfxtp_2
XTAP_TAPCELL_ROW_66_1042 VGND VPWR sky130_fd_sc_hd__tapvpwrvgnd_1
XFILLER_34_285 VGND VGND VPWR VPWR sky130_fd_sc_hd__decap_3
XFILLER_62_572 VGND VGND VPWR VPWR sky130_fd_sc_hd__decap_3
XTAP_TAPCELL_ROW_17_461 VGND VPWR sky130_fd_sc_hd__tapvpwrvgnd_1
XTAP_TAPCELL_ROW_17_450 VGND VPWR sky130_fd_sc_hd__tapvpwrvgnd_1
XTAP_TAPCELL_ROW_45_792 VGND VPWR sky130_fd_sc_hd__tapvpwrvgnd_1
XFILLER_30_480 VGND VGND VPWR VPWR sky130_fd_sc_hd__decap_3
X_4705_ _6995_/Q _6996_/Q _4963_/A VGND VGND VPWR VPWR _4931_/A sky130_fd_sc_hd__and3_2
XFILLER_108_519 VGND VGND VPWR VPWR sky130_fd_sc_hd__decap_3
X_4636_ _4186_/A _4636_/B VGND VGND VPWR VPWR _4639_/A sky130_fd_sc_hd__and2b_2
XPHY_EDGE_ROW_62_Left_179 VGND VGND VPWR VPWR sky130_fd_sc_hd__decap_3
XFILLER_116_530 VGND VGND VPWR VPWR sky130_fd_sc_hd__fill_2
X_7355_ _7355_/CLK _7355_/D _6635_/Y VGND VGND VPWR VPWR _7355_/Q sky130_fd_sc_hd__dfrtp_2
Xhold610 _6782_/Q VGND VGND VPWR VPWR _6782_/D sky130_fd_sc_hd__dlygate4sd3_1
Xhold621 _6961_/Q VGND VGND VPWR VPWR _6961_/D sky130_fd_sc_hd__dlygate4sd3_1
XFILLER_116_552 VGND VGND VPWR VPWR sky130_fd_sc_hd__decap_3
Xhold632 _6962_/Q VGND VGND VPWR VPWR _6962_/D sky130_fd_sc_hd__dlygate4sd3_1
Xhold643 _6765_/Q VGND VGND VPWR VPWR _6765_/D sky130_fd_sc_hd__dlygate4sd3_1
Xhold654 _6865_/Q VGND VGND VPWR VPWR _6865_/D sky130_fd_sc_hd__dlygate4sd3_1
X_6306_ _6617_/A VGND VGND VPWR VPWR _6306_/Y sky130_fd_sc_hd__inv_2
X_4567_ _7297_/Q _4577_/B VGND VGND VPWR VPWR _7297_/D sky130_fd_sc_hd__and2_2
XTAP_TAPCELL_ROW_77_1171 VGND VPWR sky130_fd_sc_hd__tapvpwrvgnd_1
XFILLER_103_202 VGND VGND VPWR VPWR sky130_fd_sc_hd__decap_3
XFILLER_89_436 VGND VGND VPWR VPWR sky130_fd_sc_hd__decap_3
X_7286_ _7317_/CLK _7286_/D _6566_/Y VGND VGND VPWR VPWR _7286_/Q sky130_fd_sc_hd__dfrtp_2
Xhold665 _6798_/Q VGND VGND VPWR VPWR _6798_/D sky130_fd_sc_hd__dlygate4sd3_1
Xhold676 _6757_/Q VGND VGND VPWR VPWR _6757_/D sky130_fd_sc_hd__dlygate4sd3_1
Xhold687 _6821_/Q VGND VGND VPWR VPWR _6821_/D sky130_fd_sc_hd__dlygate4sd3_1
XFILLER_77_609 VGND VGND VPWR VPWR sky130_fd_sc_hd__decap_3
Xhold698 _6955_/Q VGND VGND VPWR VPWR _6955_/D sky130_fd_sc_hd__dlygate4sd3_1
X_3449_ _3449_/A _3449_/B _3449_/C VGND VGND VPWR VPWR _3449_/X sky130_fd_sc_hd__and3_2
XFILLER_103_279 VGND VGND VPWR VPWR sky130_fd_sc_hd__fill_1
XFILLER_69_160 VGND VGND VPWR VPWR sky130_fd_sc_hd__decap_3
XFILLER_76_108 VGND VGND VPWR VPWR sky130_fd_sc_hd__decap_3
XFILLER_85_620 VGND VGND VPWR VPWR sky130_fd_sc_hd__decap_3
XFILLER_94_18 VGND VGND VPWR VPWR sky130_fd_sc_hd__decap_3
XFILLER_111_290 VGND VGND VPWR VPWR sky130_fd_sc_hd__fill_2
XFILLER_57_322 VGND VGND VPWR VPWR sky130_fd_sc_hd__decap_3
XFILLER_69_193 VGND VGND VPWR VPWR sky130_fd_sc_hd__decap_3
XFILLER_85_653 VGND VGND VPWR VPWR sky130_fd_sc_hd__decap_3
XFILLER_94_29 VGND VGND VPWR VPWR sky130_fd_sc_hd__fill_2
XFILLER_97_491 VGND VGND VPWR VPWR sky130_fd_sc_hd__decap_3
X_5119_ _5670_/A _5670_/B _6984_/Q VGND VGND VPWR VPWR _5120_/B sky130_fd_sc_hd__a21oi_2
XFILLER_17_208 VGND VGND VPWR VPWR sky130_fd_sc_hd__decap_3
XFILLER_57_366 VGND VGND VPWR VPWR sky130_fd_sc_hd__decap_3
XFILLER_84_141 VGND VGND VPWR VPWR sky130_fd_sc_hd__fill_2
XFILLER_84_163 VGND VGND VPWR VPWR sky130_fd_sc_hd__decap_3
XPHY_EDGE_ROW_71_Left_188 VGND VGND VPWR VPWR sky130_fd_sc_hd__decap_3
XFILLER_27_67 VGND VGND VPWR VPWR sky130_fd_sc_hd__decap_3
XFILLER_27_78 VGND VGND VPWR VPWR sky130_fd_sc_hd__decap_3
XFILLER_72_336 VGND VGND VPWR VPWR sky130_fd_sc_hd__decap_3
XFILLER_25_263 VGND VGND VPWR VPWR sky130_fd_sc_hd__decap_3
XFILLER_40_200 VGND VGND VPWR VPWR sky130_fd_sc_hd__decap_3
XFILLER_53_594 VGND VGND VPWR VPWR sky130_fd_sc_hd__decap_3
XFILLER_13_458 VGND VGND VPWR VPWR sky130_fd_sc_hd__decap_3
XFILLER_25_296 VGND VGND VPWR VPWR sky130_fd_sc_hd__decap_3
XFILLER_80_380 VGND VGND VPWR VPWR sky130_fd_sc_hd__fill_2
XFILLER_40_277 VGND VGND VPWR VPWR sky130_fd_sc_hd__fill_1
XFILLER_43_99 VGND VGND VPWR VPWR sky130_fd_sc_hd__decap_3
XFILLER_21_491 VGND VGND VPWR VPWR sky130_fd_sc_hd__fill_1
XFILLER_40_288 VGND VGND VPWR VPWR sky130_fd_sc_hd__decap_3
XPHY_EDGE_ROW_80_Left_197 VGND VGND VPWR VPWR sky130_fd_sc_hd__decap_3
XFILLER_5_635 VGND VGND VPWR VPWR sky130_fd_sc_hd__decap_3
XFILLER_107_541 VGND VGND VPWR VPWR sky130_fd_sc_hd__decap_3
XFILLER_4_167 VGND VGND VPWR VPWR sky130_fd_sc_hd__decap_3
XFILLER_5_668 VGND VGND VPWR VPWR sky130_fd_sc_hd__decap_3
XFILLER_5_679 VGND VGND VPWR VPWR sky130_fd_sc_hd__decap_3
XFILLER_107_585 VGND VGND VPWR VPWR sky130_fd_sc_hd__decap_3
XFILLER_95_406 VGND VGND VPWR VPWR sky130_fd_sc_hd__decap_3
XFILLER_0_351 VGND VGND VPWR VPWR sky130_fd_sc_hd__decap_3
XFILLER_68_96 VGND VGND VPWR VPWR sky130_fd_sc_hd__decap_3
XFILLER_95_439 VGND VGND VPWR VPWR sky130_fd_sc_hd__decap_3
XFILLER_76_631 VGND VGND VPWR VPWR sky130_fd_sc_hd__decap_3
XFILLER_63_303 VGND VGND VPWR VPWR sky130_fd_sc_hd__decap_3
XFILLER_75_152 VGND VGND VPWR VPWR sky130_fd_sc_hd__decap_3
XFILLER_76_675 VGND VGND VPWR VPWR sky130_fd_sc_hd__decap_3
XFILLER_91_612 VGND VGND VPWR VPWR sky130_fd_sc_hd__decap_3
XFILLER_29_591 VGND VGND VPWR VPWR sky130_fd_sc_hd__decap_3
XFILLER_84_62 VGND VGND VPWR VPWR sky130_fd_sc_hd__fill_1
XFILLER_91_623 VGND VGND VPWR VPWR sky130_fd_sc_hd__decap_3
Xplace303 _3640_/X VGND VGND VPWR VPWR _3665_/B sky130_fd_sc_hd__buf_2
XFILLER_63_369 VGND VGND VPWR VPWR sky130_fd_sc_hd__decap_3
XFILLER_90_144 VGND VGND VPWR VPWR sky130_fd_sc_hd__fill_2
XFILLER_91_656 VGND VGND VPWR VPWR sky130_fd_sc_hd__decap_3
Xplace336 _4351_/B1 VGND VGND VPWR VPWR _4267_/A2 sky130_fd_sc_hd__buf_2
Xplace325 _4356_/A2 VGND VGND VPWR VPWR _4422_/A2 sky130_fd_sc_hd__buf_2
Xplace314 _3522_/Y VGND VGND VPWR VPWR _5020_/A sky130_fd_sc_hd__buf_2
XFILLER_44_572 VGND VGND VPWR VPWR sky130_fd_sc_hd__decap_3
XFILLER_90_177 VGND VGND VPWR VPWR sky130_fd_sc_hd__decap_3
Xplace369 _4347_/C1 VGND VGND VPWR VPWR _4429_/C1 sky130_fd_sc_hd__buf_2
Xplace358 _4979_/S VGND VGND VPWR VPWR _4823_/S sky130_fd_sc_hd__buf_2
Xplace347 _3609_/B VGND VGND VPWR VPWR _5114_/A sky130_fd_sc_hd__buf_2
XFILLER_31_211 VGND VGND VPWR VPWR sky130_fd_sc_hd__decap_3
XFILLER_31_222 VGND VGND VPWR VPWR sky130_fd_sc_hd__fill_2
XFILLER_71_391 VGND VGND VPWR VPWR sky130_fd_sc_hd__fill_1
XFILLER_90_6 VGND VGND VPWR VPWR sky130_fd_sc_hd__decap_3
XTAP_TAPCELL_ROW_14_420 VGND VPWR sky130_fd_sc_hd__tapvpwrvgnd_1
XFILLER_31_255 VGND VGND VPWR VPWR sky130_fd_sc_hd__fill_1
XFILLER_31_277 VGND VGND VPWR VPWR sky130_fd_sc_hd__decap_3
XTAP_TAPCELL_ROW_42_751 VGND VPWR sky130_fd_sc_hd__tapvpwrvgnd_1
XFILLER_69_3 VGND VGND VPWR VPWR sky130_fd_sc_hd__decap_3
X_4421_ _7240_/Q _4421_/A2 _4459_/C1 _7176_/Q _4420_/X VGND VGND VPWR VPWR _4421_/X
+ sky130_fd_sc_hd__a221o_2
XTAP_TAPCELL_ROW_113_1603 VGND VPWR sky130_fd_sc_hd__tapvpwrvgnd_1
XFILLER_113_500 VGND VGND VPWR VPWR sky130_fd_sc_hd__decap_3
XFILLER_113_511 VGND VGND VPWR VPWR sky130_fd_sc_hd__decap_3
X_7140_ _7364_/CLK _7140_/D _6420_/Y VGND VGND VPWR VPWR _7140_/Q sky130_fd_sc_hd__dfrtp_2
X_4352_ _7289_/Q _5080_/S _4352_/B1 _7161_/Q _4351_/X VGND VGND VPWR VPWR _4352_/X
+ sky130_fd_sc_hd__a221o_2
XFILLER_113_544 VGND VGND VPWR VPWR sky130_fd_sc_hd__decap_3
XFILLER_4_690 VGND VGND VPWR VPWR sky130_fd_sc_hd__fill_1
XFILLER_59_609 VGND VGND VPWR VPWR sky130_fd_sc_hd__decap_3
X_7071_ _7404_/CLK _7071_/D _6351_/Y VGND VGND VPWR VPWR _7071_/Q sky130_fd_sc_hd__dfrtp_2
X_4283_ _7094_/Q _4335_/B1 _4351_/B1 _7126_/Q VGND VGND VPWR VPWR _4283_/X sky130_fd_sc_hd__a22o_2
X_3303_ _4467_/A _3519_/B _3302_/X VGND VGND VPWR VPWR _6981_/D sky130_fd_sc_hd__o21a_4
XFILLER_100_205 VGND VGND VPWR VPWR sky130_fd_sc_hd__decap_3
XFILLER_113_588 VGND VGND VPWR VPWR sky130_fd_sc_hd__decap_3
XFILLER_39_300 VGND VGND VPWR VPWR sky130_fd_sc_hd__fill_2
XFILLER_100_227 VGND VGND VPWR VPWR sky130_fd_sc_hd__fill_1
XFILLER_67_620 VGND VGND VPWR VPWR sky130_fd_sc_hd__decap_3
XFILLER_67_653 VGND VGND VPWR VPWR sky130_fd_sc_hd__decap_3
XFILLER_39_355 VGND VGND VPWR VPWR sky130_fd_sc_hd__fill_1
XFILLER_39_377 VGND VGND VPWR VPWR sky130_fd_sc_hd__fill_1
XFILLER_82_601 VGND VGND VPWR VPWR sky130_fd_sc_hd__decap_3
XFILLER_54_336 VGND VGND VPWR VPWR sky130_fd_sc_hd__fill_1
XFILLER_66_185 VGND VGND VPWR VPWR sky130_fd_sc_hd__fill_2
XFILLER_82_634 VGND VGND VPWR VPWR sky130_fd_sc_hd__decap_3
XFILLER_82_645 VGND VGND VPWR VPWR sky130_fd_sc_hd__decap_3
XFILLER_82_678 VGND VGND VPWR VPWR sky130_fd_sc_hd__decap_3
X_6924_ _6965_/CLK _6924_/D VGND VGND VPWR VPWR _6924_/Q sky130_fd_sc_hd__dfxtp_2
XFILLER_22_200 VGND VGND VPWR VPWR sky130_fd_sc_hd__fill_1
XFILLER_35_561 VGND VGND VPWR VPWR sky130_fd_sc_hd__decap_3
XFILLER_22_211 VGND VGND VPWR VPWR sky130_fd_sc_hd__decap_3
XFILLER_35_594 VGND VGND VPWR VPWR sky130_fd_sc_hd__decap_3
XFILLER_81_199 VGND VGND VPWR VPWR sky130_fd_sc_hd__decap_3
Xfanout26 fanout33/X VGND VGND VPWR VPWR _6632_/A sky130_fd_sc_hd__buf_2
Xfanout37 _6636_/A VGND VGND VPWR VPWR _6537_/A sky130_fd_sc_hd__buf_1
X_6855_ _6974_/CLK _6855_/D VGND VGND VPWR VPWR _6855_/Q sky130_fd_sc_hd__dfxtp_2
XFILLER_10_417 VGND VGND VPWR VPWR sky130_fd_sc_hd__decap_3
XFILLER_22_244 VGND VGND VPWR VPWR sky130_fd_sc_hd__decap_3
XFILLER_50_575 VGND VGND VPWR VPWR sky130_fd_sc_hd__decap_3
Xfanout48 _6686_/A VGND VGND VPWR VPWR _6673_/A sky130_fd_sc_hd__buf_2
Xfanout59 _6582_/A VGND VGND VPWR VPWR _6613_/A sky130_fd_sc_hd__buf_1
X_6786_ _7378_/CLK _6786_/D VGND VGND VPWR VPWR _6786_/Q sky130_fd_sc_hd__dfxtp_2
X_5737_ _7374_/Q hold910/X _5737_/S VGND VGND VPWR VPWR _6718_/D sky130_fd_sc_hd__mux2_2
XTAP_TAPCELL_ROW_79_1200 VGND VPWR sky130_fd_sc_hd__tapvpwrvgnd_1
X_5668_ _5668_/A _5668_/B VGND VGND VPWR VPWR _6980_/D sky130_fd_sc_hd__or2_2
XTAP_TAPCELL_ROW_20_489 VGND VPWR sky130_fd_sc_hd__tapvpwrvgnd_1
X_4619_ _5086_/A _4619_/B _5101_/B _5073_/A VGND VGND VPWR VPWR _4619_/Y sky130_fd_sc_hd__nor4_1
XFILLER_104_522 VGND VGND VPWR VPWR sky130_fd_sc_hd__decap_3
XFILLER_116_371 VGND VGND VPWR VPWR sky130_fd_sc_hd__decap_3
XFILLER_2_616 VGND VGND VPWR VPWR sky130_fd_sc_hd__decap_3
XFILLER_89_222 VGND VGND VPWR VPWR sky130_fd_sc_hd__fill_2
X_7338_ _7368_/CLK _7338_/D _6618_/Y VGND VGND VPWR VPWR _7338_/Q sky130_fd_sc_hd__dfrtp_2
XFILLER_104_533 VGND VGND VPWR VPWR sky130_fd_sc_hd__decap_3
XFILLER_104_566 VGND VGND VPWR VPWR sky130_fd_sc_hd__decap_3
XFILLER_116_393 VGND VGND VPWR VPWR sky130_fd_sc_hd__decap_3
X_7269_ _7395_/CLK _7269_/D _6549_/Y VGND VGND VPWR VPWR _7269_/Q sky130_fd_sc_hd__dfrtp_2
XFILLER_38_11 VGND VGND VPWR VPWR sky130_fd_sc_hd__fill_1
XFILLER_58_631 VGND VGND VPWR VPWR sky130_fd_sc_hd__decap_3
XFILLER_45_303 VGND VGND VPWR VPWR sky130_fd_sc_hd__decap_3
XFILLER_58_675 VGND VGND VPWR VPWR sky130_fd_sc_hd__decap_3
XFILLER_73_612 VGND VGND VPWR VPWR sky130_fd_sc_hd__decap_3
XFILLER_92_409 VGND VGND VPWR VPWR sky130_fd_sc_hd__decap_3
Xhold1140 _7156_/Q VGND VGND VPWR VPWR _5350_/A0 sky130_fd_sc_hd__dlygate4sd3_1
Xhold1151 _7314_/Q VGND VGND VPWR VPWR _4530_/A0 sky130_fd_sc_hd__dlygate4sd3_1
XFILLER_18_539 VGND VGND VPWR VPWR sky130_fd_sc_hd__decap_3
XFILLER_45_325 VGND VGND VPWR VPWR sky130_fd_sc_hd__decap_3
XFILLER_72_100 VGND VGND VPWR VPWR sky130_fd_sc_hd__decap_3
XFILLER_73_623 VGND VGND VPWR VPWR sky130_fd_sc_hd__decap_3
Xhold1162 _7329_/Q VGND VGND VPWR VPWR _4501_/A0 sky130_fd_sc_hd__dlygate4sd3_1
Xhold1173 _7155_/Q VGND VGND VPWR VPWR _5352_/A0 sky130_fd_sc_hd__dlygate4sd3_1
Xhold1184 _7174_/Q VGND VGND VPWR VPWR _5312_/A0 sky130_fd_sc_hd__dlygate4sd3_1
XFILLER_72_144 VGND VGND VPWR VPWR sky130_fd_sc_hd__decap_3
XFILLER_73_656 VGND VGND VPWR VPWR sky130_fd_sc_hd__decap_3
Xhold1195 _7220_/Q VGND VGND VPWR VPWR _5217_/A sky130_fd_sc_hd__dlygate4sd3_1
XFILLER_26_583 VGND VGND VPWR VPWR sky130_fd_sc_hd__decap_3
XFILLER_60_306 VGND VGND VPWR VPWR sky130_fd_sc_hd__fill_2
XFILLER_72_166 VGND VGND VPWR VPWR sky130_fd_sc_hd__decap_3
XTAP_TAPCELL_ROW_28_589 VGND VPWR sky130_fd_sc_hd__tapvpwrvgnd_1
XFILLER_13_211 VGND VGND VPWR VPWR sky130_fd_sc_hd__decap_3
XPHY_EDGE_ROW_109_Left_226 VGND VGND VPWR VPWR sky130_fd_sc_hd__decap_3
XFILLER_110_71 VGND VGND VPWR VPWR sky130_fd_sc_hd__decap_3
XFILLER_13_255 VGND VGND VPWR VPWR sky130_fd_sc_hd__decap_3
XFILLER_41_564 VGND VGND VPWR VPWR sky130_fd_sc_hd__decap_3
XFILLER_9_204 VGND VGND VPWR VPWR sky130_fd_sc_hd__decap_3
XFILLER_41_597 VGND VGND VPWR VPWR sky130_fd_sc_hd__decap_3
XFILLER_9_248 VGND VGND VPWR VPWR sky130_fd_sc_hd__decap_3
Xclkload18 _7351_/CLK VGND VGND VPWR VPWR clkload18/Y sky130_fd_sc_hd__clkinv_2
Xclkload29 _7404_/CLK VGND VGND VPWR VPWR clkload29/Y sky130_fd_sc_hd__inv_6
XFILLER_55_9 VGND VGND VPWR VPWR sky130_fd_sc_hd__decap_3
XFILLER_107_393 VGND VGND VPWR VPWR sky130_fd_sc_hd__decap_3
XFILLER_110_525 VGND VGND VPWR VPWR sky130_fd_sc_hd__decap_3
XFILLER_1_671 VGND VGND VPWR VPWR sky130_fd_sc_hd__fill_1
XFILLER_95_214 VGND VGND VPWR VPWR sky130_fd_sc_hd__decap_3
XFILLER_110_536 VGND VGND VPWR VPWR sky130_fd_sc_hd__decap_3
XFILLER_1_682 VGND VGND VPWR VPWR sky130_fd_sc_hd__decap_3
XFILLER_49_620 VGND VGND VPWR VPWR sky130_fd_sc_hd__decap_3
XFILLER_68_439 VGND VGND VPWR VPWR sky130_fd_sc_hd__fill_1
XFILLER_95_236 VGND VGND VPWR VPWR sky130_fd_sc_hd__decap_3
XFILLER_95_247 VGND VGND VPWR VPWR sky130_fd_sc_hd__decap_3
XFILLER_95_50 VGND VGND VPWR VPWR sky130_fd_sc_hd__decap_3
XFILLER_110_569 VGND VGND VPWR VPWR sky130_fd_sc_hd__decap_3
XFILLER_49_653 VGND VGND VPWR VPWR sky130_fd_sc_hd__decap_3
XFILLER_64_601 VGND VGND VPWR VPWR sky130_fd_sc_hd__decap_3
XFILLER_83_409 VGND VGND VPWR VPWR sky130_fd_sc_hd__decap_3
XFILLER_36_336 VGND VGND VPWR VPWR sky130_fd_sc_hd__fill_1
XFILLER_48_174 VGND VGND VPWR VPWR sky130_fd_sc_hd__fill_2
XFILLER_64_634 VGND VGND VPWR VPWR sky130_fd_sc_hd__decap_3
XFILLER_64_645 VGND VGND VPWR VPWR sky130_fd_sc_hd__decap_3
XTAP_TAPCELL_ROW_47_821 VGND VPWR sky130_fd_sc_hd__tapvpwrvgnd_1
XTAP_TAPCELL_ROW_47_810 VGND VPWR sky130_fd_sc_hd__tapvpwrvgnd_1
XFILLER_24_509 VGND VGND VPWR VPWR sky130_fd_sc_hd__decap_3
XFILLER_64_678 VGND VGND VPWR VPWR sky130_fd_sc_hd__decap_3
XFILLER_17_550 VGND VGND VPWR VPWR sky130_fd_sc_hd__decap_3
XFILLER_17_561 VGND VGND VPWR VPWR sky130_fd_sc_hd__decap_3
XFILLER_51_328 VGND VGND VPWR VPWR sky130_fd_sc_hd__decap_3
XFILLER_91_486 VGND VGND VPWR VPWR sky130_fd_sc_hd__fill_2
X_4970_ _4970_/A1 _4950_/B _4967_/B _5033_/B2 VGND VGND VPWR VPWR _4970_/X sky130_fd_sc_hd__a22o_2
XFILLER_17_594 VGND VGND VPWR VPWR sky130_fd_sc_hd__decap_3
XFILLER_32_531 VGND VGND VPWR VPWR sky130_fd_sc_hd__fill_1
X_3921_ _6914_/Q _3921_/A2 _5660_/B _6688_/Q VGND VGND VPWR VPWR _3921_/X sky130_fd_sc_hd__a22o_2
XTAP_TAPCELL_ROW_63_1012 VGND VPWR sky130_fd_sc_hd__tapvpwrvgnd_1
XFILLER_32_564 VGND VGND VPWR VPWR sky130_fd_sc_hd__decap_3
X_6640_ _6640_/A VGND VGND VPWR VPWR _6640_/Y sky130_fd_sc_hd__inv_2
X_3852_ _6748_/Q _3892_/A2 _3852_/B1 _6742_/Q VGND VGND VPWR VPWR _3852_/X sky130_fd_sc_hd__a22o_2
X_6571_ _6571_/A VGND VGND VPWR VPWR _6571_/Y sky130_fd_sc_hd__inv_2
X_3783_ _6812_/Q _3890_/B1 _3852_/B1 _6822_/Q _3782_/X VGND VGND VPWR VPWR _3783_/X
+ sky130_fd_sc_hd__a221o_2
Xoutput501 _3417_/C VGND VGND VPWR VPWR instruction_out[21] sky130_fd_sc_hd__clkdlybuf4s25_1
Xoutput545 _5129_/A VGND VGND VPWR VPWR pc_out[5] sky130_fd_sc_hd__clkdlybuf4s25_1
Xoutput534 _7001_/Q VGND VGND VPWR VPWR pc_out[24] sky130_fd_sc_hd__clkdlybuf4s25_1
Xoutput523 _6991_/Q VGND VGND VPWR VPWR pc_out[14] sky130_fd_sc_hd__clkdlybuf4s25_1
Xoutput512 _5640_/Y VGND VGND VPWR VPWR instruction_out[4] sky130_fd_sc_hd__clkdlybuf4s25_1
X_4404_ _7306_/Q _4823_/S _4434_/A2 _7114_/Q VGND VGND VPWR VPWR _4404_/X sky130_fd_sc_hd__a22o_2
XFILLER_99_520 VGND VGND VPWR VPWR sky130_fd_sc_hd__decap_3
XFILLER_113_330 VGND VGND VPWR VPWR sky130_fd_sc_hd__decap_3
X_7123_ _7317_/CLK _7123_/D _6403_/Y VGND VGND VPWR VPWR _7123_/Q sky130_fd_sc_hd__dfrtp_2
X_4335_ _7287_/Q _5157_/S _4335_/B1 _7095_/Q VGND VGND VPWR VPWR _4336_/C sky130_fd_sc_hd__a22o_2
XTAP_TAPCELL_ROW_74_1141 VGND VPWR sky130_fd_sc_hd__tapvpwrvgnd_1
XFILLER_99_564 VGND VGND VPWR VPWR sky130_fd_sc_hd__decap_3
XFILLER_99_553 VGND VGND VPWR VPWR sky130_fd_sc_hd__decap_3
XFILLER_101_514 VGND VGND VPWR VPWR sky130_fd_sc_hd__decap_3
XFILLER_113_363 VGND VGND VPWR VPWR sky130_fd_sc_hd__decap_3
XFILLER_115_27 VGND VGND VPWR VPWR sky130_fd_sc_hd__decap_3
XFILLER_86_203 VGND VGND VPWR VPWR sky130_fd_sc_hd__decap_3
XFILLER_99_597 VGND VGND VPWR VPWR sky130_fd_sc_hd__decap_3
XFILLER_101_547 VGND VGND VPWR VPWR sky130_fd_sc_hd__decap_3
XFILLER_113_396 VGND VGND VPWR VPWR sky130_fd_sc_hd__decap_3
XFILLER_86_236 VGND VGND VPWR VPWR sky130_fd_sc_hd__decap_3
X_7054_ _7374_/CLK _7054_/D _6334_/Y VGND VGND VPWR VPWR _7054_/Q sky130_fd_sc_hd__dfrtp_2
X_4266_ _7294_/Q _5108_/S _4335_/B1 _7102_/Q VGND VGND VPWR VPWR _4271_/A sky130_fd_sc_hd__a22o_2
XFILLER_67_461 VGND VGND VPWR VPWR sky130_fd_sc_hd__fill_1
X_4197_ _7199_/Q _3958_/S _4269_/B1 _7044_/Q _4196_/X VGND VGND VPWR VPWR _4197_/X
+ sky130_fd_sc_hd__a221o_2
XFILLER_27_314 VGND VGND VPWR VPWR sky130_fd_sc_hd__decap_3
XFILLER_55_612 VGND VGND VPWR VPWR sky130_fd_sc_hd__decap_3
XFILLER_55_623 VGND VGND VPWR VPWR sky130_fd_sc_hd__decap_3
XFILLER_39_196 VGND VGND VPWR VPWR sky130_fd_sc_hd__fill_2
XFILLER_54_133 VGND VGND VPWR VPWR sky130_fd_sc_hd__decap_3
XFILLER_55_656 VGND VGND VPWR VPWR sky130_fd_sc_hd__decap_3
XFILLER_82_442 VGND VGND VPWR VPWR sky130_fd_sc_hd__decap_3
XFILLER_42_306 VGND VGND VPWR VPWR sky130_fd_sc_hd__fill_2
XFILLER_42_328 VGND VGND VPWR VPWR sky130_fd_sc_hd__decap_3
XFILLER_54_155 VGND VGND VPWR VPWR sky130_fd_sc_hd__decap_3
XFILLER_70_604 VGND VGND VPWR VPWR sky130_fd_sc_hd__decap_3
XFILLER_70_637 VGND VGND VPWR VPWR sky130_fd_sc_hd__decap_3
XFILLER_82_475 VGND VGND VPWR VPWR sky130_fd_sc_hd__fill_1
XFILLER_35_391 VGND VGND VPWR VPWR sky130_fd_sc_hd__fill_1
XFILLER_70_648 VGND VGND VPWR VPWR sky130_fd_sc_hd__decap_3
X_6907_ clkload6/A _6907_/D VGND VGND VPWR VPWR _6907_/Q sky130_fd_sc_hd__dfxtp_2
XTAP_TAPCELL_ROW_85_1270 VGND VPWR sky130_fd_sc_hd__tapvpwrvgnd_1
XTAP_TAPCELL_ROW_25_548 VGND VPWR sky130_fd_sc_hd__tapvpwrvgnd_1
XFILLER_23_564 VGND VGND VPWR VPWR sky130_fd_sc_hd__decap_3
XFILLER_50_350 VGND VGND VPWR VPWR sky130_fd_sc_hd__decap_3
X_6838_ _6970_/CLK _6838_/D VGND VGND VPWR VPWR _6838_/Q sky130_fd_sc_hd__dfxtp_2
XFILLER_23_597 VGND VGND VPWR VPWR sky130_fd_sc_hd__decap_3
XFILLER_24_68 VGND VGND VPWR VPWR sky130_fd_sc_hd__decap_3
XFILLER_109_603 VGND VGND VPWR VPWR sky130_fd_sc_hd__decap_3
X_6769_ _6968_/CLK _6769_/D VGND VGND VPWR VPWR _6769_/Q sky130_fd_sc_hd__dfxtp_2
XFILLER_109_647 VGND VGND VPWR VPWR sky130_fd_sc_hd__decap_3
XFILLER_40_23 VGND VGND VPWR VPWR sky130_fd_sc_hd__decap_3
XFILLER_108_135 VGND VGND VPWR VPWR sky130_fd_sc_hd__decap_3
XFILLER_104_330 VGND VGND VPWR VPWR sky130_fd_sc_hd__decap_3
XFILLER_104_374 VGND VGND VPWR VPWR sky130_fd_sc_hd__decap_3
XFILLER_49_54 VGND VGND VPWR VPWR sky130_fd_sc_hd__fill_2
XFILLER_49_65 VGND VGND VPWR VPWR sky130_fd_sc_hd__fill_2
XFILLER_77_247 VGND VGND VPWR VPWR sky130_fd_sc_hd__decap_3
XFILLER_105_60 VGND VGND VPWR VPWR sky130_fd_sc_hd__decap_3
XFILLER_46_601 VGND VGND VPWR VPWR sky130_fd_sc_hd__decap_3
XFILLER_58_450 VGND VGND VPWR VPWR sky130_fd_sc_hd__decap_3
XFILLER_105_82 VGND VGND VPWR VPWR sky130_fd_sc_hd__fill_1
XFILLER_46_634 VGND VGND VPWR VPWR sky130_fd_sc_hd__decap_3
XFILLER_58_483 VGND VGND VPWR VPWR sky130_fd_sc_hd__fill_2
XFILLER_46_645 VGND VGND VPWR VPWR sky130_fd_sc_hd__decap_3
XFILLER_46_678 VGND VGND VPWR VPWR sky130_fd_sc_hd__decap_3
XFILLER_61_615 VGND VGND VPWR VPWR sky130_fd_sc_hd__fill_1
XFILLER_61_626 VGND VGND VPWR VPWR sky130_fd_sc_hd__decap_3
XFILLER_45_199 VGND VGND VPWR VPWR sky130_fd_sc_hd__decap_3
XFILLER_61_659 VGND VGND VPWR VPWR sky130_fd_sc_hd__decap_3
XFILLER_14_542 VGND VGND VPWR VPWR sky130_fd_sc_hd__decap_3
XFILLER_14_575 VGND VGND VPWR VPWR sky130_fd_sc_hd__decap_3
XFILLER_81_41 VGND VGND VPWR VPWR sky130_fd_sc_hd__decap_3
XFILLER_41_361 VGND VGND VPWR VPWR sky130_fd_sc_hd__decap_3
XFILLER_81_96 VGND VGND VPWR VPWR sky130_fd_sc_hd__fill_2
XTAP_TAPCELL_ROW_99_1439 VGND VPWR sky130_fd_sc_hd__tapvpwrvgnd_1
XFILLER_115_606 VGND VGND VPWR VPWR sky130_fd_sc_hd__decap_3
XFILLER_115_617 VGND VGND VPWR VPWR sky130_fd_sc_hd__decap_3
XPHY_EDGE_ROW_116_Right_116 VGND VGND VPWR VPWR sky130_fd_sc_hd__decap_3
XFILLER_5_251 VGND VGND VPWR VPWR sky130_fd_sc_hd__decap_3
XFILLER_5_284 VGND VGND VPWR VPWR sky130_fd_sc_hd__decap_3
XFILLER_68_203 VGND VGND VPWR VPWR sky130_fd_sc_hd__fill_1
XFILLER_96_512 VGND VGND VPWR VPWR sky130_fd_sc_hd__decap_3
XFILLER_110_300 VGND VGND VPWR VPWR sky130_fd_sc_hd__decap_3
XFILLER_68_236 VGND VGND VPWR VPWR sky130_fd_sc_hd__fill_2
XFILLER_96_545 VGND VGND VPWR VPWR sky130_fd_sc_hd__decap_3
X_4120_ _7300_/Q _4979_/S _4351_/A2 _7108_/Q VGND VGND VPWR VPWR _4120_/X sky130_fd_sc_hd__a22o_2
XFILLER_1_490 VGND VGND VPWR VPWR sky130_fd_sc_hd__decap_3
XFILLER_68_269 VGND VGND VPWR VPWR sky130_fd_sc_hd__decap_3
XFILLER_96_578 VGND VGND VPWR VPWR sky130_fd_sc_hd__decap_3
XFILLER_96_589 VGND VGND VPWR VPWR sky130_fd_sc_hd__decap_3
XFILLER_37_612 VGND VGND VPWR VPWR sky130_fd_sc_hd__decap_3
XFILLER_37_623 VGND VGND VPWR VPWR sky130_fd_sc_hd__decap_3
XFILLER_49_461 VGND VGND VPWR VPWR sky130_fd_sc_hd__decap_3
XFILLER_83_217 VGND VGND VPWR VPWR sky130_fd_sc_hd__decap_3
XFILLER_36_144 VGND VGND VPWR VPWR sky130_fd_sc_hd__fill_1
XFILLER_37_656 VGND VGND VPWR VPWR sky130_fd_sc_hd__decap_3
XTAP_TAPCELL_ROW_108_1546 VGND VPWR sky130_fd_sc_hd__tapvpwrvgnd_1
XFILLER_24_317 VGND VGND VPWR VPWR sky130_fd_sc_hd__decap_3
XFILLER_52_604 VGND VGND VPWR VPWR sky130_fd_sc_hd__decap_3
XFILLER_91_261 VGND VGND VPWR VPWR sky130_fd_sc_hd__fill_1
XFILLER_52_637 VGND VGND VPWR VPWR sky130_fd_sc_hd__decap_3
XFILLER_52_648 VGND VGND VPWR VPWR sky130_fd_sc_hd__decap_3
X_4953_ _4950_/A _4381_/A _4969_/C _5020_/A VGND VGND VPWR VPWR _4953_/Y sky130_fd_sc_hd__a31oi_2
XFILLER_51_169 VGND VGND VPWR VPWR sky130_fd_sc_hd__fill_1
X_3904_ _3904_/A _3904_/B VGND VGND VPWR VPWR _3904_/Y sky130_fd_sc_hd__nand2_2
XFILLER_32_361 VGND VGND VPWR VPWR sky130_fd_sc_hd__decap_3
XFILLER_60_681 VGND VGND VPWR VPWR sky130_fd_sc_hd__decap_3
X_6623_ _6663_/A VGND VGND VPWR VPWR _6623_/Y sky130_fd_sc_hd__inv_2
X_4884_ _4884_/A _4904_/B VGND VGND VPWR VPWR _4884_/X sky130_fd_sc_hd__or2_2
XTAP_TAPCELL_ROW_50_849 VGND VPWR sky130_fd_sc_hd__tapvpwrvgnd_1
XTAP_TAPCELL_ROW_22_518 VGND VPWR sky130_fd_sc_hd__tapvpwrvgnd_1
XFILLER_20_545 VGND VGND VPWR VPWR sky130_fd_sc_hd__decap_3
X_3835_ _6725_/Q _3886_/A2 _3886_/B1 _6975_/Q VGND VGND VPWR VPWR _3835_/X sky130_fd_sc_hd__a22o_2
XFILLER_20_578 VGND VGND VPWR VPWR sky130_fd_sc_hd__decap_3
XFILLER_20_589 VGND VGND VPWR VPWR sky130_fd_sc_hd__decap_3
X_6554_ _6649_/A VGND VGND VPWR VPWR _6554_/Y sky130_fd_sc_hd__inv_2
X_3766_ hold974/X _3822_/A2 _4927_/B VGND VGND VPWR VPWR _7394_/D sky130_fd_sc_hd__a21o_2
X_6485_ _6652_/A VGND VGND VPWR VPWR _6485_/Y sky130_fd_sc_hd__inv_2
XFILLER_105_116 VGND VGND VPWR VPWR sky130_fd_sc_hd__decap_3
XFILLER_106_628 VGND VGND VPWR VPWR sky130_fd_sc_hd__decap_3
XFILLER_10_26 VGND VGND VPWR VPWR sky130_fd_sc_hd__fill_2
X_3697_ _3682_/A _3696_/X _4791_/A1 VGND VGND VPWR VPWR _3697_/Y sky130_fd_sc_hd__a21oi_2
XFILLER_10_59 VGND VGND VPWR VPWR sky130_fd_sc_hd__decap_3
XFILLER_114_672 VGND VGND VPWR VPWR sky130_fd_sc_hd__decap_3
X_5367_ _5367_/A0 _4734_/X _5383_/S VGND VGND VPWR VPWR _7149_/D sky130_fd_sc_hd__mux2_2
XFILLER_101_322 VGND VGND VPWR VPWR sky130_fd_sc_hd__fill_1
XFILLER_59_225 VGND VGND VPWR VPWR sky130_fd_sc_hd__decap_3
XFILLER_87_534 VGND VGND VPWR VPWR sky130_fd_sc_hd__decap_3
X_7106_ _7332_/CLK _7106_/D _6386_/Y VGND VGND VPWR VPWR _7106_/Q sky130_fd_sc_hd__dfrtp_2
X_5298_ _5298_/A0 _4734_/X _5315_/S VGND VGND VPWR VPWR _7181_/D sky130_fd_sc_hd__mux2_2
X_4318_ _7290_/Q _4517_/S _4318_/B1 _7162_/Q _4317_/X VGND VGND VPWR VPWR _4318_/X
+ sky130_fd_sc_hd__a221o_2
XFILLER_101_355 VGND VGND VPWR VPWR sky130_fd_sc_hd__decap_3
XFILLER_113_193 VGND VGND VPWR VPWR sky130_fd_sc_hd__decap_3
XFILLER_87_567 VGND VGND VPWR VPWR sky130_fd_sc_hd__decap_3
X_7037_ _7353_/CLK _7037_/D _6317_/Y VGND VGND VPWR VPWR _7037_/Q sky130_fd_sc_hd__dfrtp_2
X_4249_ _7069_/Q _4305_/B _4460_/A VGND VGND VPWR VPWR _4626_/C sky130_fd_sc_hd__o21a_2
XFILLER_101_377 VGND VGND VPWR VPWR sky130_fd_sc_hd__decap_3
XFILLER_19_57 VGND VGND VPWR VPWR sky130_fd_sc_hd__decap_3
XFILLER_28_601 VGND VGND VPWR VPWR sky130_fd_sc_hd__decap_3
XFILLER_28_634 VGND VGND VPWR VPWR sky130_fd_sc_hd__decap_3
XFILLER_74_206 VGND VGND VPWR VPWR sky130_fd_sc_hd__decap_3
XTAP_TAPCELL_ROW_58_949 VGND VPWR sky130_fd_sc_hd__tapvpwrvgnd_1
XFILLER_28_645 VGND VGND VPWR VPWR sky130_fd_sc_hd__decap_3
XFILLER_28_678 VGND VGND VPWR VPWR sky130_fd_sc_hd__decap_3
XFILLER_43_615 VGND VGND VPWR VPWR sky130_fd_sc_hd__fill_1
XFILLER_43_626 VGND VGND VPWR VPWR sky130_fd_sc_hd__decap_3
XFILLER_55_475 VGND VGND VPWR VPWR sky130_fd_sc_hd__decap_3
XTAP_TAPCELL_ROW_2_276 VGND VPWR sky130_fd_sc_hd__tapvpwrvgnd_1
XFILLER_42_136 VGND VGND VPWR VPWR sky130_fd_sc_hd__decap_3
XFILLER_43_659 VGND VGND VPWR VPWR sky130_fd_sc_hd__decap_3
XFILLER_82_294 VGND VGND VPWR VPWR sky130_fd_sc_hd__decap_3
XFILLER_30_309 VGND VGND VPWR VPWR sky130_fd_sc_hd__fill_2
XFILLER_23_383 VGND VGND VPWR VPWR sky130_fd_sc_hd__decap_3
XFILLER_11_556 VGND VGND VPWR VPWR sky130_fd_sc_hd__decap_3
XFILLER_11_567 VGND VGND VPWR VPWR sky130_fd_sc_hd__decap_3
XFILLER_7_538 VGND VGND VPWR VPWR sky130_fd_sc_hd__decap_3
XFILLER_109_444 VGND VGND VPWR VPWR sky130_fd_sc_hd__decap_3
XFILLER_109_455 VGND VGND VPWR VPWR sky130_fd_sc_hd__decap_3
XFILLER_109_488 VGND VGND VPWR VPWR sky130_fd_sc_hd__decap_3
XFILLER_105_650 VGND VGND VPWR VPWR sky130_fd_sc_hd__decap_3
XFILLER_78_545 VGND VGND VPWR VPWR sky130_fd_sc_hd__decap_3
XFILLER_104_193 VGND VGND VPWR VPWR sky130_fd_sc_hd__decap_3
XFILLER_116_81 VGND VGND VPWR VPWR sky130_fd_sc_hd__decap_3
XFILLER_78_578 VGND VGND VPWR VPWR sky130_fd_sc_hd__decap_3
XFILLER_19_612 VGND VGND VPWR VPWR sky130_fd_sc_hd__decap_3
XFILLER_19_623 VGND VGND VPWR VPWR sky130_fd_sc_hd__decap_3
XFILLER_65_228 VGND VGND VPWR VPWR sky130_fd_sc_hd__decap_3
XFILLER_76_85 VGND VGND VPWR VPWR sky130_fd_sc_hd__fill_2
XFILLER_78_589 VGND VGND VPWR VPWR sky130_fd_sc_hd__decap_3
XFILLER_93_526 VGND VGND VPWR VPWR sky130_fd_sc_hd__decap_3
XFILLER_19_656 VGND VGND VPWR VPWR sky130_fd_sc_hd__decap_3
XFILLER_46_431 VGND VGND VPWR VPWR sky130_fd_sc_hd__decap_3
XFILLER_93_559 VGND VGND VPWR VPWR sky130_fd_sc_hd__fill_1
XFILLER_34_604 VGND VGND VPWR VPWR sky130_fd_sc_hd__decap_3
XFILLER_46_486 VGND VGND VPWR VPWR sky130_fd_sc_hd__decap_3
XFILLER_73_261 VGND VGND VPWR VPWR sky130_fd_sc_hd__decap_3
XFILLER_34_637 VGND VGND VPWR VPWR sky130_fd_sc_hd__decap_3
XFILLER_34_648 VGND VGND VPWR VPWR sky130_fd_sc_hd__decap_3
XFILLER_61_423 VGND VGND VPWR VPWR sky130_fd_sc_hd__decap_3
XFILLER_21_309 VGND VGND VPWR VPWR sky130_fd_sc_hd__decap_3
XFILLER_33_169 VGND VGND VPWR VPWR sky130_fd_sc_hd__decap_3
XFILLER_42_681 VGND VGND VPWR VPWR sky130_fd_sc_hd__decap_3
XTAP_TAPCELL_ROW_103_1487 VGND VPWR sky130_fd_sc_hd__tapvpwrvgnd_1
X_3620_ _3620_/A _4292_/B _3620_/C VGND VGND VPWR VPWR _3620_/X sky130_fd_sc_hd__or3_4
X_3551_ _3508_/A _3547_/Y _3550_/X VGND VGND VPWR VPWR _3551_/X sky130_fd_sc_hd__a21o_2
XFILLER_115_414 VGND VGND VPWR VPWR sky130_fd_sc_hd__decap_3
XFILLER_6_560 VGND VGND VPWR VPWR sky130_fd_sc_hd__decap_3
XFILLER_115_447 VGND VGND VPWR VPWR sky130_fd_sc_hd__fill_1
XFILLER_115_458 VGND VGND VPWR VPWR sky130_fd_sc_hd__decap_3
X_6270_ _6364_/A VGND VGND VPWR VPWR _6270_/Y sky130_fd_sc_hd__inv_2
X_3482_ _3482_/A _3482_/B _3482_/C VGND VGND VPWR VPWR _3482_/Y sky130_fd_sc_hd__nor3_2
XFILLER_103_609 VGND VGND VPWR VPWR sky130_fd_sc_hd__decap_3
XFILLER_88_309 VGND VGND VPWR VPWR sky130_fd_sc_hd__fill_1
X_5221_ _5221_/A _5225_/B VGND VGND VPWR VPWR _7218_/D sky130_fd_sc_hd__and2_2
XTAP_TAPCELL_ROW_71_1100 VGND VPWR sky130_fd_sc_hd__tapvpwrvgnd_1
XFILLER_111_620 VGND VGND VPWR VPWR sky130_fd_sc_hd__decap_3
X_5152_ _7009_/Q _5152_/B VGND VGND VPWR VPWR _5152_/Y sky130_fd_sc_hd__nand2_2
XFILLER_111_653 VGND VGND VPWR VPWR sky130_fd_sc_hd__decap_3
XFILLER_69_567 VGND VGND VPWR VPWR sky130_fd_sc_hd__decap_3
XFILLER_96_331 VGND VGND VPWR VPWR sky130_fd_sc_hd__decap_3
X_4103_ _7365_/Q _4093_/B _4267_/B1 _7173_/Q VGND VGND VPWR VPWR _4103_/X sky130_fd_sc_hd__a22o_2
XFILLER_56_217 VGND VGND VPWR VPWR sky130_fd_sc_hd__decap_3
X_5083_ _5086_/A _4343_/X VGND VGND VPWR VPWR _5083_/X sky130_fd_sc_hd__or2b_2
XFILLER_56_239 VGND VGND VPWR VPWR sky130_fd_sc_hd__decap_3
XFILLER_84_548 VGND VGND VPWR VPWR sky130_fd_sc_hd__decap_3
X_4034_ _7150_/Q _4434_/B1 _4032_/X _4033_/X VGND VGND VPWR VPWR _4034_/X sky130_fd_sc_hd__a211o_2
XTAP_TAPCELL_ROW_55_908 VGND VPWR sky130_fd_sc_hd__tapvpwrvgnd_1
XFILLER_25_615 VGND VGND VPWR VPWR sky130_fd_sc_hd__fill_1
XFILLER_25_626 VGND VGND VPWR VPWR sky130_fd_sc_hd__decap_3
XFILLER_25_659 VGND VGND VPWR VPWR sky130_fd_sc_hd__decap_3
XFILLER_37_486 VGND VGND VPWR VPWR sky130_fd_sc_hd__decap_3
XFILLER_64_283 VGND VGND VPWR VPWR sky130_fd_sc_hd__decap_3
XFILLER_92_581 VGND VGND VPWR VPWR sky130_fd_sc_hd__decap_3
XFILLER_92_592 VGND VGND VPWR VPWR sky130_fd_sc_hd__decap_3
XTAP_TAPCELL_ROW_69_1084 VGND VPWR sky130_fd_sc_hd__tapvpwrvgnd_1
XFILLER_12_309 VGND VGND VPWR VPWR sky130_fd_sc_hd__decap_3
XFILLER_40_607 VGND VGND VPWR VPWR sky130_fd_sc_hd__decap_3
XFILLER_52_445 VGND VGND VPWR VPWR sky130_fd_sc_hd__decap_3
XTAP_TAPCELL_ROW_82_1240 VGND VPWR sky130_fd_sc_hd__tapvpwrvgnd_1
X_4936_ _4936_/A _4936_/B VGND VGND VPWR VPWR _4936_/Y sky130_fd_sc_hd__xnor2_2
XTAP_TAPCELL_ROW_35_676 VGND VPWR sky130_fd_sc_hd__tapvpwrvgnd_1
XANTENNA_10 _4434_/A2 VGND VGND VPWR VPWR sky130_fd_sc_hd__diode_2
XFILLER_20_331 VGND VGND VPWR VPWR sky130_fd_sc_hd__fill_2
X_4867_ _6998_/Q _4912_/A VGND VGND VPWR VPWR _4882_/A sky130_fd_sc_hd__nand2_2
X_6606_ _6638_/A VGND VGND VPWR VPWR _6606_/Y sky130_fd_sc_hd__inv_2
X_3818_ _3818_/A1 _3833_/S _3817_/X VGND VGND VPWR VPWR _7390_/D sky130_fd_sc_hd__o21a_2
X_6537_ _6537_/A VGND VGND VPWR VPWR _6537_/Y sky130_fd_sc_hd__inv_2
X_4798_ _4811_/C _4795_/X _4796_/Y _4797_/X VGND VGND VPWR VPWR _5656_/A sky130_fd_sc_hd__a211o_2
XFILLER_4_519 VGND VGND VPWR VPWR sky130_fd_sc_hd__decap_3
X_3749_ _3726_/X _3734_/X _3748_/X _3991_/A VGND VGND VPWR VPWR _3749_/Y sky130_fd_sc_hd__o31ai_2
X_6468_ _6663_/A VGND VGND VPWR VPWR _6468_/Y sky130_fd_sc_hd__inv_2
XFILLER_106_469 VGND VGND VPWR VPWR sky130_fd_sc_hd__decap_3
X_6399_ _6625_/A VGND VGND VPWR VPWR _6399_/Y sky130_fd_sc_hd__inv_2
X_5419_ _5419_/A0 _5131_/X _5429_/S VGND VGND VPWR VPWR _7124_/D sky130_fd_sc_hd__mux2_2
XFILLER_102_631 VGND VGND VPWR VPWR sky130_fd_sc_hd__decap_3
XFILLER_114_480 VGND VGND VPWR VPWR sky130_fd_sc_hd__decap_3
XTAP_TAPCELL_ROW_7_335 VGND VPWR sky130_fd_sc_hd__tapvpwrvgnd_1
XFILLER_101_152 VGND VGND VPWR VPWR sky130_fd_sc_hd__decap_3
XFILLER_102_675 VGND VGND VPWR VPWR sky130_fd_sc_hd__decap_3
XFILLER_47_239 VGND VGND VPWR VPWR sky130_fd_sc_hd__decap_3
XFILLER_75_559 VGND VGND VPWR VPWR sky130_fd_sc_hd__fill_1
XFILLER_16_604 VGND VGND VPWR VPWR sky130_fd_sc_hd__decap_3
XFILLER_46_55 VGND VGND VPWR VPWR sky130_fd_sc_hd__decap_3
XFILLER_55_261 VGND VGND VPWR VPWR sky130_fd_sc_hd__decap_3
XFILLER_83_570 VGND VGND VPWR VPWR sky130_fd_sc_hd__decap_3
XFILLER_16_637 VGND VGND VPWR VPWR sky130_fd_sc_hd__decap_3
XFILLER_16_648 VGND VGND VPWR VPWR sky130_fd_sc_hd__decap_3
XFILLER_43_434 VGND VGND VPWR VPWR sky130_fd_sc_hd__decap_3
XFILLER_70_220 VGND VGND VPWR VPWR sky130_fd_sc_hd__decap_3
XFILLER_15_136 VGND VGND VPWR VPWR sky130_fd_sc_hd__decap_3
XFILLER_15_169 VGND VGND VPWR VPWR sky130_fd_sc_hd__decap_3
XFILLER_62_21 VGND VGND VPWR VPWR sky130_fd_sc_hd__decap_3
XFILLER_70_253 VGND VGND VPWR VPWR sky130_fd_sc_hd__decap_3
XFILLER_24_681 VGND VGND VPWR VPWR sky130_fd_sc_hd__decap_3
XFILLER_31_629 VGND VGND VPWR VPWR sky130_fd_sc_hd__decap_3
XFILLER_43_489 VGND VGND VPWR VPWR sky130_fd_sc_hd__decap_3
XFILLER_62_32 VGND VGND VPWR VPWR sky130_fd_sc_hd__decap_3
XFILLER_70_275 VGND VGND VPWR VPWR sky130_fd_sc_hd__decap_3
XFILLER_11_331 VGND VGND VPWR VPWR sky130_fd_sc_hd__decap_3
XFILLER_62_76 VGND VGND VPWR VPWR sky130_fd_sc_hd__decap_3
XFILLER_7_16 VGND VGND VPWR VPWR sky130_fd_sc_hd__decap_3
XFILLER_7_324 VGND VGND VPWR VPWR sky130_fd_sc_hd__decap_3
XFILLER_7_346 VGND VGND VPWR VPWR sky130_fd_sc_hd__decap_3
XFILLER_7_357 VGND VGND VPWR VPWR sky130_fd_sc_hd__decap_3
XTAP_TAPCELL_ROW_96_1409 VGND VPWR sky130_fd_sc_hd__tapvpwrvgnd_1
XFILLER_112_406 VGND VGND VPWR VPWR sky130_fd_sc_hd__decap_3
XFILLER_3_541 VGND VGND VPWR VPWR sky130_fd_sc_hd__decap_3
XFILLER_98_607 VGND VGND VPWR VPWR sky130_fd_sc_hd__decap_3
XFILLER_105_480 VGND VGND VPWR VPWR sky130_fd_sc_hd__decap_3
XFILLER_112_439 VGND VGND VPWR VPWR sky130_fd_sc_hd__decap_3
XFILLER_3_585 VGND VGND VPWR VPWR sky130_fd_sc_hd__decap_3
XFILLER_78_342 VGND VGND VPWR VPWR sky130_fd_sc_hd__fill_1
XFILLER_78_386 VGND VGND VPWR VPWR sky130_fd_sc_hd__fill_2
XFILLER_19_442 VGND VGND VPWR VPWR sky130_fd_sc_hd__decap_3
XFILLER_46_261 VGND VGND VPWR VPWR sky130_fd_sc_hd__decap_3
XFILLER_46_272 VGND VGND VPWR VPWR sky130_fd_sc_hd__decap_3
XFILLER_74_581 VGND VGND VPWR VPWR sky130_fd_sc_hd__decap_3
XFILLER_74_592 VGND VGND VPWR VPWR sky130_fd_sc_hd__decap_3
XTAP_TAPCELL_ROW_105_1516 VGND VPWR sky130_fd_sc_hd__tapvpwrvgnd_1
XFILLER_22_607 VGND VGND VPWR VPWR sky130_fd_sc_hd__decap_3
XFILLER_61_242 VGND VGND VPWR VPWR sky130_fd_sc_hd__fill_1
XFILLER_34_489 VGND VGND VPWR VPWR sky130_fd_sc_hd__decap_3
XFILLER_30_640 VGND VGND VPWR VPWR sky130_fd_sc_hd__decap_3
X_4721_ _5071_/A _4658_/A _4055_/A VGND VGND VPWR VPWR _4721_/Y sky130_fd_sc_hd__a21oi_2
XTAP_TAPCELL_ROW_60_966 VGND VPWR sky130_fd_sc_hd__tapvpwrvgnd_1
XTAP_TAPCELL_ROW_32_635 VGND VPWR sky130_fd_sc_hd__tapvpwrvgnd_1
XFILLER_30_651 VGND VGND VPWR VPWR sky130_fd_sc_hd__decap_3
X_4652_ _4652_/A _4652_/B VGND VGND VPWR VPWR _4785_/A sky130_fd_sc_hd__nor2_2
XTAP_TAPCELL_ROW_60_977 VGND VPWR sky130_fd_sc_hd__tapvpwrvgnd_1
XFILLER_30_684 VGND VGND VPWR VPWR sky130_fd_sc_hd__decap_3
X_3603_ _4614_/B _3603_/B VGND VGND VPWR VPWR _3603_/Y sky130_fd_sc_hd__nand2_2
X_7371_ _7405_/CLK _7371_/D _6651_/Y VGND VGND VPWR VPWR _7371_/Q sky130_fd_sc_hd__dfrtp_2
Xhold803 _6902_/Q VGND VGND VPWR VPWR _6902_/D sky130_fd_sc_hd__dlygate4sd3_1
X_4583_ _4583_/A _4595_/B VGND VGND VPWR VPWR _7289_/D sky130_fd_sc_hd__and2_2
XTAP_TAPCELL_ROW_12_392 VGND VPWR sky130_fd_sc_hd__tapvpwrvgnd_1
XFILLER_115_233 VGND VGND VPWR VPWR sky130_fd_sc_hd__fill_1
Xhold814 _6758_/Q VGND VGND VPWR VPWR _6758_/D sky130_fd_sc_hd__dlygate4sd3_1
Xhold825 _6830_/Q VGND VGND VPWR VPWR _6830_/D sky130_fd_sc_hd__dlygate4sd3_1
Xhold836 _6969_/Q VGND VGND VPWR VPWR _6969_/D sky130_fd_sc_hd__dlygate4sd3_1
X_6322_ _6642_/A VGND VGND VPWR VPWR _6322_/Y sky130_fd_sc_hd__inv_2
X_3534_ _3509_/Y _3510_/X _4285_/B1 VGND VGND VPWR VPWR _3534_/Y sky130_fd_sc_hd__a21oi_2
XTAP_TAPCELL_ROW_116_1656 VGND VPWR sky130_fd_sc_hd__tapvpwrvgnd_1
XTAP_TAPCELL_ROW_116_1645 VGND VPWR sky130_fd_sc_hd__tapvpwrvgnd_1
XFILLER_107_39 VGND VGND VPWR VPWR sky130_fd_sc_hd__decap_3
XFILLER_115_255 VGND VGND VPWR VPWR sky130_fd_sc_hd__decap_3
XFILLER_89_629 VGND VGND VPWR VPWR sky130_fd_sc_hd__decap_3
Xhold847 _7068_/Q VGND VGND VPWR VPWR _7068_/D sky130_fd_sc_hd__dlygate4sd3_1
Xhold858 _7115_/Q VGND VGND VPWR VPWR _7115_/D sky130_fd_sc_hd__dlygate4sd3_1
Xhold869 _7055_/Q VGND VGND VPWR VPWR _7055_/D sky130_fd_sc_hd__dlygate4sd3_1
Xmax_cap566 _3383_/Y VGND VGND VPWR VPWR _3562_/A sky130_fd_sc_hd__buf_2
X_3465_ _7185_/Q _3996_/S _4278_/B1 _7377_/Q VGND VGND VPWR VPWR _3465_/X sky130_fd_sc_hd__a22o_2
XFILLER_88_139 VGND VGND VPWR VPWR sky130_fd_sc_hd__fill_1
XTAP_TAPCELL_ROW_4_305 VGND VPWR sky130_fd_sc_hd__tapvpwrvgnd_1
XFILLER_97_662 VGND VGND VPWR VPWR sky130_fd_sc_hd__decap_3
XFILLER_111_461 VGND VGND VPWR VPWR sky130_fd_sc_hd__decap_3
XFILLER_96_150 VGND VGND VPWR VPWR sky130_fd_sc_hd__decap_3
X_5135_ _3324_/A _5666_/A _5595_/B _5134_/X VGND VGND VPWR VPWR _5135_/X sky130_fd_sc_hd__a211o_2
XFILLER_97_673 VGND VGND VPWR VPWR sky130_fd_sc_hd__decap_3
XFILLER_111_494 VGND VGND VPWR VPWR sky130_fd_sc_hd__decap_3
XFILLER_29_228 VGND VGND VPWR VPWR sky130_fd_sc_hd__decap_3
X_5066_ _5066_/A _5066_/B VGND VGND VPWR VPWR _6987_/D sky130_fd_sc_hd__nor2_2
X_4017_ _7310_/Q _4478_/S _4459_/C1 _7182_/Q VGND VGND VPWR VPWR _4017_/X sky130_fd_sc_hd__a22o_2
XFILLER_65_570 VGND VGND VPWR VPWR sky130_fd_sc_hd__decap_3
XFILLER_25_445 VGND VGND VPWR VPWR sky130_fd_sc_hd__decap_3
XFILLER_52_253 VGND VGND VPWR VPWR sky130_fd_sc_hd__fill_2
XFILLER_80_551 VGND VGND VPWR VPWR sky130_fd_sc_hd__decap_3
XFILLER_13_629 VGND VGND VPWR VPWR sky130_fd_sc_hd__decap_3
XFILLER_40_404 VGND VGND VPWR VPWR sky130_fd_sc_hd__fill_1
XFILLER_80_584 VGND VGND VPWR VPWR sky130_fd_sc_hd__decap_3
XFILLER_80_595 VGND VGND VPWR VPWR sky130_fd_sc_hd__decap_3
XFILLER_52_297 VGND VGND VPWR VPWR sky130_fd_sc_hd__decap_3
X_4919_ _4937_/A _4936_/B _4938_/B VGND VGND VPWR VPWR _4920_/B sky130_fd_sc_hd__o21ba_2
XFILLER_21_662 VGND VGND VPWR VPWR sky130_fd_sc_hd__decap_3
XFILLER_21_673 VGND VGND VPWR VPWR sky130_fd_sc_hd__decap_3
XFILLER_106_266 VGND VGND VPWR VPWR sky130_fd_sc_hd__decap_3
XFILLER_79_106 VGND VGND VPWR VPWR sky130_fd_sc_hd__fill_1
XFILLER_0_511 VGND VGND VPWR VPWR sky130_fd_sc_hd__fill_2
XTAP_TAPCELL_ROW_91_1339 VGND VPWR sky130_fd_sc_hd__tapvpwrvgnd_1
XFILLER_0_533 VGND VGND VPWR VPWR sky130_fd_sc_hd__fill_2
XFILLER_0_555 VGND VGND VPWR VPWR sky130_fd_sc_hd__decap_3
XFILLER_88_640 VGND VGND VPWR VPWR sky130_fd_sc_hd__decap_3
XFILLER_88_651 VGND VGND VPWR VPWR sky130_fd_sc_hd__decap_3
XFILLER_87_172 VGND VGND VPWR VPWR sky130_fd_sc_hd__fill_1
XFILLER_88_684 VGND VGND VPWR VPWR sky130_fd_sc_hd__decap_3
XFILLER_102_483 VGND VGND VPWR VPWR sky130_fd_sc_hd__decap_3
XFILLER_57_65 VGND VGND VPWR VPWR sky130_fd_sc_hd__fill_1
XFILLER_75_323 VGND VGND VPWR VPWR sky130_fd_sc_hd__fill_1
XFILLER_90_304 VGND VGND VPWR VPWR sky130_fd_sc_hd__decap_3
XFILLER_113_60 VGND VGND VPWR VPWR sky130_fd_sc_hd__decap_3
XFILLER_56_570 VGND VGND VPWR VPWR sky130_fd_sc_hd__decap_3
XFILLER_56_592 VGND VGND VPWR VPWR sky130_fd_sc_hd__decap_3
XFILLER_90_326 VGND VGND VPWR VPWR sky130_fd_sc_hd__decap_3
XFILLER_28_294 VGND VGND VPWR VPWR sky130_fd_sc_hd__decap_3
XFILLER_43_242 VGND VGND VPWR VPWR sky130_fd_sc_hd__decap_3
XFILLER_90_359 VGND VGND VPWR VPWR sky130_fd_sc_hd__decap_3
XFILLER_43_275 VGND VGND VPWR VPWR sky130_fd_sc_hd__decap_3
XFILLER_71_573 VGND VGND VPWR VPWR sky130_fd_sc_hd__decap_3
XFILLER_73_97 VGND VGND VPWR VPWR sky130_fd_sc_hd__decap_3
XFILLER_12_640 VGND VGND VPWR VPWR sky130_fd_sc_hd__decap_3
XFILLER_12_651 VGND VGND VPWR VPWR sky130_fd_sc_hd__decap_3
XFILLER_8_622 VGND VGND VPWR VPWR sky130_fd_sc_hd__decap_3
XTAP_TAPCELL_ROW_100_1457 VGND VPWR sky130_fd_sc_hd__tapvpwrvgnd_1
XTAP_TAPCELL_ROW_100_1446 VGND VPWR sky130_fd_sc_hd__tapvpwrvgnd_1
XFILLER_11_172 VGND VGND VPWR VPWR sky130_fd_sc_hd__decap_3
XFILLER_12_684 VGND VGND VPWR VPWR sky130_fd_sc_hd__decap_3
XFILLER_7_154 VGND VGND VPWR VPWR sky130_fd_sc_hd__decap_3
XFILLER_7_165 VGND VGND VPWR VPWR sky130_fd_sc_hd__decap_3
XFILLER_8_666 VGND VGND VPWR VPWR sky130_fd_sc_hd__decap_3
XFILLER_98_404 VGND VGND VPWR VPWR sky130_fd_sc_hd__decap_3
XFILLER_112_236 VGND VGND VPWR VPWR sky130_fd_sc_hd__decap_3
XFILLER_3_393 VGND VGND VPWR VPWR sky130_fd_sc_hd__fill_2
XFILLER_100_409 VGND VGND VPWR VPWR sky130_fd_sc_hd__decap_3
XFILLER_66_312 VGND VGND VPWR VPWR sky130_fd_sc_hd__decap_3
XFILLER_79_662 VGND VGND VPWR VPWR sky130_fd_sc_hd__decap_3
XFILLER_79_673 VGND VGND VPWR VPWR sky130_fd_sc_hd__decap_3
XFILLER_85_109 VGND VGND VPWR VPWR sky130_fd_sc_hd__decap_3
XFILLER_94_610 VGND VGND VPWR VPWR sky130_fd_sc_hd__decap_3
XTAP_TAPCELL_ROW_111_1586 VGND VPWR sky130_fd_sc_hd__tapvpwrvgnd_1
XFILLER_78_183 VGND VGND VPWR VPWR sky130_fd_sc_hd__decap_3
XFILLER_78_194 VGND VGND VPWR VPWR sky130_fd_sc_hd__fill_2
XFILLER_94_643 VGND VGND VPWR VPWR sky130_fd_sc_hd__fill_1
XFILLER_94_654 VGND VGND VPWR VPWR sky130_fd_sc_hd__decap_3
XFILLER_94_687 VGND VGND VPWR VPWR sky130_fd_sc_hd__decap_3
X_6940_ _6941_/CLK _6940_/D VGND VGND VPWR VPWR _6940_/Q sky130_fd_sc_hd__dfxtp_2
XFILLER_47_570 VGND VGND VPWR VPWR sky130_fd_sc_hd__decap_3
XFILLER_81_337 VGND VGND VPWR VPWR sky130_fd_sc_hd__fill_1
XFILLER_34_220 VGND VGND VPWR VPWR sky130_fd_sc_hd__fill_2
XFILLER_62_551 VGND VGND VPWR VPWR sky130_fd_sc_hd__decap_3
XFILLER_81_359 VGND VGND VPWR VPWR sky130_fd_sc_hd__decap_3
X_6871_ _7398_/CLK _6871_/D VGND VGND VPWR VPWR _6871_/Q sky130_fd_sc_hd__dfxtp_2
XTAP_TAPCELL_ROW_66_1043 VGND VPWR sky130_fd_sc_hd__tapvpwrvgnd_1
XFILLER_34_264 VGND VGND VPWR VPWR sky130_fd_sc_hd__decap_3
XFILLER_62_584 VGND VGND VPWR VPWR sky130_fd_sc_hd__decap_3
XTAP_TAPCELL_ROW_17_451 VGND VPWR sky130_fd_sc_hd__tapvpwrvgnd_1
XFILLER_34_297 VGND VGND VPWR VPWR sky130_fd_sc_hd__decap_3
XFILLER_62_595 VGND VGND VPWR VPWR sky130_fd_sc_hd__decap_3
XTAP_TAPCELL_ROW_45_793 VGND VPWR sky130_fd_sc_hd__tapvpwrvgnd_1
X_4704_ _6994_/Q _4977_/A VGND VGND VPWR VPWR _4963_/A sky130_fd_sc_hd__and2_2
XFILLER_30_470 VGND VGND VPWR VPWR sky130_fd_sc_hd__decap_3
X_5684_ _7348_/Q hold920/X _5703_/S VGND VGND VPWR VPWR _6692_/D sky130_fd_sc_hd__mux2_2
X_4635_ _4916_/A _4916_/B _4633_/X _4634_/Y VGND VGND VPWR VPWR _4646_/A sky130_fd_sc_hd__a211o_2
X_7354_ _7392_/CLK _7354_/D _6634_/Y VGND VGND VPWR VPWR _7354_/Q sky130_fd_sc_hd__dfrtp_2
Xhold600 _6973_/Q VGND VGND VPWR VPWR _6973_/D sky130_fd_sc_hd__dlygate4sd3_1
Xhold611 _6874_/Q VGND VGND VPWR VPWR _6874_/D sky130_fd_sc_hd__dlygate4sd3_1
Xhold622 _6949_/Q VGND VGND VPWR VPWR _6949_/D sky130_fd_sc_hd__dlygate4sd3_1
Xhold633 _6841_/Q VGND VGND VPWR VPWR _6841_/D sky130_fd_sc_hd__dlygate4sd3_1
Xhold644 _6778_/Q VGND VGND VPWR VPWR _6778_/D sky130_fd_sc_hd__dlygate4sd3_1
X_6305_ _6586_/A VGND VGND VPWR VPWR _6305_/Y sky130_fd_sc_hd__inv_2
X_3517_ _3386_/B _3370_/Y _3516_/X VGND VGND VPWR VPWR _3525_/A sky130_fd_sc_hd__a21bo_2
XTAP_TAPCELL_ROW_77_1172 VGND VPWR sky130_fd_sc_hd__tapvpwrvgnd_1
XFILLER_103_225 VGND VGND VPWR VPWR sky130_fd_sc_hd__fill_1
XFILLER_116_575 VGND VGND VPWR VPWR sky130_fd_sc_hd__decap_3
X_7285_ _7317_/CLK _7285_/D _6565_/Y VGND VGND VPWR VPWR _7285_/Q sky130_fd_sc_hd__dfrtp_2
Xhold655 _6760_/Q VGND VGND VPWR VPWR _6760_/D sky130_fd_sc_hd__dlygate4sd3_1
Xhold666 _6934_/Q VGND VGND VPWR VPWR _6934_/D sky130_fd_sc_hd__dlygate4sd3_1
Xhold677 _6883_/Q VGND VGND VPWR VPWR _6883_/D sky130_fd_sc_hd__dlygate4sd3_1
Xhold688 _6913_/Q VGND VGND VPWR VPWR _6913_/D sky130_fd_sc_hd__dlygate4sd3_1
X_4497_ _4497_/A0 _7299_/Q _4505_/S VGND VGND VPWR VPWR _7331_/D sky130_fd_sc_hd__mux2_2
Xhold699 _6853_/Q VGND VGND VPWR VPWR _6853_/D sky130_fd_sc_hd__dlygate4sd3_1
X_3448_ _7282_/Q _5157_/S _4352_/B1 _7154_/Q _3447_/X VGND VGND VPWR VPWR _3448_/X
+ sky130_fd_sc_hd__a221o_2
X_3379_ _7219_/Q _3377_/X _4279_/B1 _7123_/Q VGND VGND VPWR VPWR _3379_/X sky130_fd_sc_hd__a22o_2
XFILLER_57_334 VGND VGND VPWR VPWR sky130_fd_sc_hd__fill_2
XFILLER_69_172 VGND VGND VPWR VPWR sky130_fd_sc_hd__decap_3
XFILLER_84_120 VGND VGND VPWR VPWR sky130_fd_sc_hd__decap_3
XFILLER_85_632 VGND VGND VPWR VPWR sky130_fd_sc_hd__decap_3
X_5118_ _5118_/A _6984_/Q _5118_/C _5118_/D VGND VGND VPWR VPWR _5118_/X sky130_fd_sc_hd__or4_2
XFILLER_85_665 VGND VGND VPWR VPWR sky130_fd_sc_hd__decap_3
XFILLER_85_676 VGND VGND VPWR VPWR sky130_fd_sc_hd__decap_3
XFILLER_27_57 VGND VGND VPWR VPWR sky130_fd_sc_hd__fill_2
XFILLER_38_581 VGND VGND VPWR VPWR sky130_fd_sc_hd__decap_3
XFILLER_38_592 VGND VGND VPWR VPWR sky130_fd_sc_hd__decap_3
XFILLER_84_197 VGND VGND VPWR VPWR sky130_fd_sc_hd__fill_1
X_5049_ _5072_/B _5073_/B _5071_/B VGND VGND VPWR VPWR _5049_/X sky130_fd_sc_hd__a21bo_2
XFILLER_25_231 VGND VGND VPWR VPWR sky130_fd_sc_hd__decap_3
XFILLER_43_23 VGND VGND VPWR VPWR sky130_fd_sc_hd__fill_2
XFILLER_53_573 VGND VGND VPWR VPWR sky130_fd_sc_hd__decap_3
XFILLER_13_426 VGND VGND VPWR VPWR sky130_fd_sc_hd__fill_2
XFILLER_13_437 VGND VGND VPWR VPWR sky130_fd_sc_hd__fill_2
XFILLER_40_212 VGND VGND VPWR VPWR sky130_fd_sc_hd__decap_3
XFILLER_40_234 VGND VGND VPWR VPWR sky130_fd_sc_hd__decap_3
XFILLER_43_45 VGND VGND VPWR VPWR sky130_fd_sc_hd__decap_3
XFILLER_40_256 VGND VGND VPWR VPWR sky130_fd_sc_hd__decap_3
XFILLER_5_603 VGND VGND VPWR VPWR sky130_fd_sc_hd__decap_3
XFILLER_107_520 VGND VGND VPWR VPWR sky130_fd_sc_hd__decap_3
XFILLER_5_647 VGND VGND VPWR VPWR sky130_fd_sc_hd__decap_3
XFILLER_107_553 VGND VGND VPWR VPWR sky130_fd_sc_hd__decap_3
XFILLER_107_564 VGND VGND VPWR VPWR sky130_fd_sc_hd__decap_3
XFILLER_107_597 VGND VGND VPWR VPWR sky130_fd_sc_hd__decap_3
XFILLER_108_71 VGND VGND VPWR VPWR sky130_fd_sc_hd__decap_3
XFILLER_4_17 VGND VGND VPWR VPWR sky130_fd_sc_hd__decap_3
XFILLER_4_179 VGND VGND VPWR VPWR sky130_fd_sc_hd__decap_3
XFILLER_76_610 VGND VGND VPWR VPWR sky130_fd_sc_hd__decap_3
XFILLER_88_470 VGND VGND VPWR VPWR sky130_fd_sc_hd__decap_3
XFILLER_48_312 VGND VGND VPWR VPWR sky130_fd_sc_hd__decap_3
XFILLER_76_643 VGND VGND VPWR VPWR sky130_fd_sc_hd__fill_1
XFILLER_102_291 VGND VGND VPWR VPWR sky130_fd_sc_hd__decap_3
XFILLER_48_345 VGND VGND VPWR VPWR sky130_fd_sc_hd__decap_3
XFILLER_76_654 VGND VGND VPWR VPWR sky130_fd_sc_hd__decap_3
XFILLER_76_687 VGND VGND VPWR VPWR sky130_fd_sc_hd__decap_3
XFILLER_29_570 VGND VGND VPWR VPWR sky130_fd_sc_hd__decap_3
XFILLER_48_389 VGND VGND VPWR VPWR sky130_fd_sc_hd__decap_3
XFILLER_63_315 VGND VGND VPWR VPWR sky130_fd_sc_hd__decap_3
XFILLER_63_337 VGND VGND VPWR VPWR sky130_fd_sc_hd__decap_3
XFILLER_75_164 VGND VGND VPWR VPWR sky130_fd_sc_hd__decap_3
XFILLER_75_175 VGND VGND VPWR VPWR sky130_fd_sc_hd__decap_3
XFILLER_91_635 VGND VGND VPWR VPWR sky130_fd_sc_hd__decap_3
Xplace304 _3634_/Y VGND VGND VPWR VPWR _3991_/B sky130_fd_sc_hd__buf_2
XFILLER_84_85 VGND VGND VPWR VPWR sky130_fd_sc_hd__decap_3
XFILLER_91_668 VGND VGND VPWR VPWR sky130_fd_sc_hd__decap_3
XFILLER_91_679 VGND VGND VPWR VPWR sky130_fd_sc_hd__decap_3
Xplace337 _3407_/X VGND VGND VPWR VPWR _4351_/B1 sky130_fd_sc_hd__buf_2
Xplace326 _4601_/S VGND VGND VPWR VPWR _4356_/A2 sky130_fd_sc_hd__buf_2
Xplace315 _4591_/B VGND VGND VPWR VPWR _4595_/B sky130_fd_sc_hd__buf_2
XFILLER_16_253 VGND VGND VPWR VPWR sky130_fd_sc_hd__fill_1
XFILLER_44_584 VGND VGND VPWR VPWR sky130_fd_sc_hd__decap_3
Xplace359 _5080_/S VGND VGND VPWR VPWR _4979_/S sky130_fd_sc_hd__buf_2
Xplace348 _3521_/Y VGND VGND VPWR VPWR _4764_/B sky130_fd_sc_hd__buf_2
XFILLER_16_286 VGND VGND VPWR VPWR sky130_fd_sc_hd__decap_3
XFILLER_44_595 VGND VGND VPWR VPWR sky130_fd_sc_hd__decap_3
XTAP_TAPCELL_ROW_14_421 VGND VPWR sky130_fd_sc_hd__tapvpwrvgnd_1
XTAP_TAPCELL_ROW_42_752 VGND VPWR sky130_fd_sc_hd__tapvpwrvgnd_1
XFILLER_12_470 VGND VGND VPWR VPWR sky130_fd_sc_hd__decap_3
XFILLER_8_430 VGND VGND VPWR VPWR sky130_fd_sc_hd__fill_1
X_4420_ _7336_/Q _3954_/S _4420_/B1 _7144_/Q VGND VGND VPWR VPWR _4420_/X sky130_fd_sc_hd__a22o_2
XTAP_TAPCELL_ROW_113_1604 VGND VPWR sky130_fd_sc_hd__tapvpwrvgnd_1
XFILLER_113_523 VGND VGND VPWR VPWR sky130_fd_sc_hd__decap_3
X_4351_ _7097_/Q _4351_/A2 _4351_/B1 _7129_/Q VGND VGND VPWR VPWR _4351_/X sky130_fd_sc_hd__a22o_2
XFILLER_113_556 VGND VGND VPWR VPWR sky130_fd_sc_hd__decap_3
X_7070_ _7404_/CLK _7070_/D _6350_/Y VGND VGND VPWR VPWR _7070_/Q sky130_fd_sc_hd__dfrtp_2
X_4282_ _7062_/Q _3577_/B _3590_/A _4281_/X VGND VGND VPWR VPWR _4294_/A sky130_fd_sc_hd__o211ai_2
X_3302_ _6980_/Q _3331_/B _3324_/A VGND VGND VPWR VPWR _3302_/X sky130_fd_sc_hd__a21o_2
XFILLER_100_217 VGND VGND VPWR VPWR sky130_fd_sc_hd__fill_2
XFILLER_113_567 VGND VGND VPWR VPWR sky130_fd_sc_hd__decap_3
XFILLER_104_18 VGND VGND VPWR VPWR sky130_fd_sc_hd__decap_3
XFILLER_67_632 VGND VGND VPWR VPWR sky130_fd_sc_hd__decap_3
XFILLER_104_29 VGND VGND VPWR VPWR sky130_fd_sc_hd__decap_3
XFILLER_67_665 VGND VGND VPWR VPWR sky130_fd_sc_hd__decap_3
XFILLER_67_676 VGND VGND VPWR VPWR sky130_fd_sc_hd__decap_3
XFILLER_54_315 VGND VGND VPWR VPWR sky130_fd_sc_hd__decap_3
XFILLER_81_101 VGND VGND VPWR VPWR sky130_fd_sc_hd__decap_3
XFILLER_82_613 VGND VGND VPWR VPWR sky130_fd_sc_hd__decap_3
XFILLER_54_348 VGND VGND VPWR VPWR sky130_fd_sc_hd__fill_2
XFILLER_54_359 VGND VGND VPWR VPWR sky130_fd_sc_hd__decap_3
XFILLER_66_197 VGND VGND VPWR VPWR sky130_fd_sc_hd__fill_2
XFILLER_82_657 VGND VGND VPWR VPWR sky130_fd_sc_hd__decap_3
X_6923_ _6966_/CLK _6923_/D VGND VGND VPWR VPWR _6923_/Q sky130_fd_sc_hd__dfxtp_2
XFILLER_35_573 VGND VGND VPWR VPWR sky130_fd_sc_hd__decap_3
XFILLER_81_167 VGND VGND VPWR VPWR sky130_fd_sc_hd__fill_1
XFILLER_81_178 VGND VGND VPWR VPWR sky130_fd_sc_hd__decap_3
XFILLER_22_223 VGND VGND VPWR VPWR sky130_fd_sc_hd__decap_3
XFILLER_90_690 VGND VGND VPWR VPWR sky130_fd_sc_hd__fill_1
Xfanout27 fanout33/X VGND VGND VPWR VPWR _6626_/A sky130_fd_sc_hd__clkdlybuf4s25_1
Xfanout38 fanout38/A VGND VGND VPWR VPWR _6636_/A sky130_fd_sc_hd__clkdlybuf4s25_1
X_6854_ _6968_/CLK _6854_/D VGND VGND VPWR VPWR _6854_/Q sky130_fd_sc_hd__dfxtp_2
XFILLER_22_267 VGND VGND VPWR VPWR sky130_fd_sc_hd__decap_3
Xfanout49 _6686_/A VGND VGND VPWR VPWR _6685_/A sky130_fd_sc_hd__buf_2
X_6785_ _6954_/CLK _6785_/D VGND VGND VPWR VPWR _6785_/Q sky130_fd_sc_hd__dfxtp_2
XFILLER_10_429 VGND VGND VPWR VPWR sky130_fd_sc_hd__decap_3
XFILLER_50_587 VGND VGND VPWR VPWR sky130_fd_sc_hd__fill_1
XFILLER_50_598 VGND VGND VPWR VPWR sky130_fd_sc_hd__decap_3
XFILLER_108_306 VGND VGND VPWR VPWR sky130_fd_sc_hd__fill_2
X_5667_ _5667_/A _5668_/B VGND VGND VPWR VPWR _6979_/D sky130_fd_sc_hd__nor2_2
XTAP_TAPCELL_ROW_79_1201 VGND VPWR sky130_fd_sc_hd__tapvpwrvgnd_1
XFILLER_108_339 VGND VGND VPWR VPWR sky130_fd_sc_hd__decap_3
X_7406_ _7406_/CLK _7406_/D _6686_/Y VGND VGND VPWR VPWR _7406_/Q sky130_fd_sc_hd__dfrtp_2
X_5598_ hold928/X _5587_/B _4468_/X VGND VGND VPWR VPWR _7028_/D sky130_fd_sc_hd__a21o_2
XFILLER_104_501 VGND VGND VPWR VPWR sky130_fd_sc_hd__decap_3
XFILLER_1_116 VGND VGND VPWR VPWR sky130_fd_sc_hd__fill_1
XFILLER_2_628 VGND VGND VPWR VPWR sky130_fd_sc_hd__decap_3
XFILLER_89_201 VGND VGND VPWR VPWR sky130_fd_sc_hd__decap_3
X_7337_ _7405_/CLK _7337_/D _6617_/Y VGND VGND VPWR VPWR _7337_/Q sky130_fd_sc_hd__dfrtp_2
XFILLER_104_545 VGND VGND VPWR VPWR sky130_fd_sc_hd__decap_3
X_7268_ _7362_/CLK _7268_/D _6548_/Y VGND VGND VPWR VPWR _7268_/Q sky130_fd_sc_hd__dfrtp_2
XFILLER_104_578 VGND VGND VPWR VPWR sky130_fd_sc_hd__decap_3
XFILLER_104_589 VGND VGND VPWR VPWR sky130_fd_sc_hd__decap_3
XFILLER_58_610 VGND VGND VPWR VPWR sky130_fd_sc_hd__decap_3
XFILLER_77_407 VGND VGND VPWR VPWR sky130_fd_sc_hd__decap_3
XFILLER_58_643 VGND VGND VPWR VPWR sky130_fd_sc_hd__fill_1
X_7199_ _7362_/CLK _7199_/D _6479_/Y VGND VGND VPWR VPWR _7199_/Q sky130_fd_sc_hd__dfrtp_2
XFILLER_57_142 VGND VGND VPWR VPWR sky130_fd_sc_hd__decap_3
XFILLER_58_654 VGND VGND VPWR VPWR sky130_fd_sc_hd__decap_3
Xhold1130 _7138_/Q VGND VGND VPWR VPWR _5390_/A0 sky130_fd_sc_hd__dlygate4sd3_1
Xhold1141 _7339_/Q VGND VGND VPWR VPWR _4480_/A0 sky130_fd_sc_hd__dlygate4sd3_1
XFILLER_18_529 VGND VGND VPWR VPWR sky130_fd_sc_hd__decap_3
XFILLER_57_175 VGND VGND VPWR VPWR sky130_fd_sc_hd__fill_1
XFILLER_58_687 VGND VGND VPWR VPWR sky130_fd_sc_hd__decap_3
XFILLER_72_112 VGND VGND VPWR VPWR sky130_fd_sc_hd__decap_3
XFILLER_73_635 VGND VGND VPWR VPWR sky130_fd_sc_hd__decap_3
Xhold1152 _7159_/Q VGND VGND VPWR VPWR _5344_/A0 sky130_fd_sc_hd__dlygate4sd3_1
Xhold1163 _7012_/Q VGND VGND VPWR VPWR _5632_/A sky130_fd_sc_hd__dlygate4sd3_1
Xhold1174 _7289_/Q VGND VGND VPWR VPWR _4583_/A sky130_fd_sc_hd__dlygate4sd3_1
Xhold1185 _7402_/Q VGND VGND VPWR VPWR _3698_/A1 sky130_fd_sc_hd__dlygate4sd3_1
XFILLER_45_337 VGND VGND VPWR VPWR sky130_fd_sc_hd__decap_3
XFILLER_57_197 VGND VGND VPWR VPWR sky130_fd_sc_hd__decap_3
XFILLER_73_668 VGND VGND VPWR VPWR sky130_fd_sc_hd__decap_3
XFILLER_73_679 VGND VGND VPWR VPWR sky130_fd_sc_hd__decap_3
Xhold1196 _7168_/Q VGND VGND VPWR VPWR _5325_/A0 sky130_fd_sc_hd__dlygate4sd3_1
XFILLER_26_562 VGND VGND VPWR VPWR sky130_fd_sc_hd__decap_3
XFILLER_60_318 VGND VGND VPWR VPWR sky130_fd_sc_hd__decap_3
XFILLER_72_189 VGND VGND VPWR VPWR sky130_fd_sc_hd__decap_3
XFILLER_13_223 VGND VGND VPWR VPWR sky130_fd_sc_hd__fill_1
XFILLER_26_595 VGND VGND VPWR VPWR sky130_fd_sc_hd__decap_3
XFILLER_110_50 VGND VGND VPWR VPWR sky130_fd_sc_hd__decap_3
XFILLER_41_554 VGND VGND VPWR VPWR sky130_fd_sc_hd__decap_3
XFILLER_41_576 VGND VGND VPWR VPWR sky130_fd_sc_hd__decap_3
XFILLER_110_83 VGND VGND VPWR VPWR sky130_fd_sc_hd__fill_1
XFILLER_70_32 VGND VGND VPWR VPWR sky130_fd_sc_hd__decap_3
XFILLER_70_54 VGND VGND VPWR VPWR sky130_fd_sc_hd__decap_3
Xclkload19 _7344_/CLK VGND VGND VPWR VPWR clkload19/Y sky130_fd_sc_hd__inv_4
XFILLER_114_309 VGND VGND VPWR VPWR sky130_fd_sc_hd__fill_1
XFILLER_107_361 VGND VGND VPWR VPWR sky130_fd_sc_hd__decap_3
XFILLER_5_499 VGND VGND VPWR VPWR sky130_fd_sc_hd__decap_3
XFILLER_79_74 VGND VGND VPWR VPWR sky130_fd_sc_hd__decap_3
XFILLER_110_504 VGND VGND VPWR VPWR sky130_fd_sc_hd__decap_3
XFILLER_1_650 VGND VGND VPWR VPWR sky130_fd_sc_hd__decap_3
XFILLER_68_418 VGND VGND VPWR VPWR sky130_fd_sc_hd__fill_2
XFILLER_110_548 VGND VGND VPWR VPWR sky130_fd_sc_hd__decap_3
XFILLER_49_632 VGND VGND VPWR VPWR sky130_fd_sc_hd__decap_3
XFILLER_49_665 VGND VGND VPWR VPWR sky130_fd_sc_hd__decap_3
XFILLER_49_676 VGND VGND VPWR VPWR sky130_fd_sc_hd__decap_3
XFILLER_95_259 VGND VGND VPWR VPWR sky130_fd_sc_hd__decap_3
XFILLER_48_186 VGND VGND VPWR VPWR sky130_fd_sc_hd__decap_3
XFILLER_64_613 VGND VGND VPWR VPWR sky130_fd_sc_hd__decap_3
XFILLER_91_410 VGND VGND VPWR VPWR sky130_fd_sc_hd__fill_2
XFILLER_91_421 VGND VGND VPWR VPWR sky130_fd_sc_hd__fill_2
XTAP_TAPCELL_ROW_47_811 VGND VPWR sky130_fd_sc_hd__tapvpwrvgnd_1
XFILLER_48_197 VGND VGND VPWR VPWR sky130_fd_sc_hd__decap_3
XFILLER_64_657 VGND VGND VPWR VPWR sky130_fd_sc_hd__decap_3
XFILLER_91_432 VGND VGND VPWR VPWR sky130_fd_sc_hd__decap_3
XFILLER_17_573 VGND VGND VPWR VPWR sky130_fd_sc_hd__decap_3
XFILLER_51_307 VGND VGND VPWR VPWR sky130_fd_sc_hd__decap_3
X_3920_ _3920_/A1 _3991_/A _3919_/X VGND VGND VPWR VPWR _7377_/D sky130_fd_sc_hd__o21a_2
XFILLER_72_690 VGND VGND VPWR VPWR sky130_fd_sc_hd__fill_1
XTAP_TAPCELL_ROW_63_1013 VGND VPWR sky130_fd_sc_hd__tapvpwrvgnd_1
XTAP_TAPCELL_ROW_63_1002 VGND VPWR sky130_fd_sc_hd__tapvpwrvgnd_1
XFILLER_32_576 VGND VGND VPWR VPWR sky130_fd_sc_hd__decap_3
X_3851_ _6825_/Q _3886_/A2 _3891_/A2 _6815_/Q _3850_/X VGND VGND VPWR VPWR _3851_/X
+ sky130_fd_sc_hd__a221o_2
XFILLER_32_598 VGND VGND VPWR VPWR sky130_fd_sc_hd__decap_3
X_6570_ _6570_/A VGND VGND VPWR VPWR _6570_/Y sky130_fd_sc_hd__inv_2
X_3782_ _6827_/Q _3886_/A2 _3891_/A2 _6817_/Q VGND VGND VPWR VPWR _3782_/X sky130_fd_sc_hd__a22o_2
Xoutput502 _3449_/A VGND VGND VPWR VPWR instruction_out[22] sky130_fd_sc_hd__clkdlybuf4s25_1
Xoutput535 _7002_/Q VGND VGND VPWR VPWR pc_out[25] sky130_fd_sc_hd__clkdlybuf4s25_1
Xoutput524 _6992_/Q VGND VGND VPWR VPWR pc_out[15] sky130_fd_sc_hd__clkdlybuf4s25_1
Xoutput513 _5643_/X VGND VGND VPWR VPWR instruction_out[5] sky130_fd_sc_hd__clkdlybuf4s25_1
X_5383_ _7141_/Q _4878_/X _5383_/S VGND VGND VPWR VPWR _7141_/D sky130_fd_sc_hd__mux2_2
X_4403_ _4403_/A VGND VGND VPWR VPWR _4411_/A sky130_fd_sc_hd__inv_2
X_7122_ _7351_/CLK _7122_/D _6402_/Y VGND VGND VPWR VPWR _7122_/Q sky130_fd_sc_hd__dfrtp_2
Xoutput546 _5670_/A VGND VGND VPWR VPWR pc_out[6] sky130_fd_sc_hd__clkdlybuf4s25_1
X_4334_ _7351_/Q _4337_/B _4352_/B1 _7159_/Q VGND VGND VPWR VPWR _4336_/B sky130_fd_sc_hd__a22o_2
XTAP_TAPCELL_ROW_74_1142 VGND VPWR sky130_fd_sc_hd__tapvpwrvgnd_1
XFILLER_99_532 VGND VGND VPWR VPWR sky130_fd_sc_hd__decap_3
XFILLER_113_375 VGND VGND VPWR VPWR sky130_fd_sc_hd__decap_3
XFILLER_59_418 VGND VGND VPWR VPWR sky130_fd_sc_hd__decap_3
X_7053_ _7406_/CLK _7053_/D _6333_/Y VGND VGND VPWR VPWR _7053_/Q sky130_fd_sc_hd__dfrtp_2
XFILLER_99_576 VGND VGND VPWR VPWR sky130_fd_sc_hd__decap_3
XFILLER_101_526 VGND VGND VPWR VPWR sky130_fd_sc_hd__decap_3
XFILLER_115_39 VGND VGND VPWR VPWR sky130_fd_sc_hd__decap_3
XFILLER_86_248 VGND VGND VPWR VPWR sky130_fd_sc_hd__fill_1
X_4265_ _7070_/Q _4265_/B VGND VGND VPWR VPWR _4376_/C sky130_fd_sc_hd__nor2_2
XFILLER_101_559 VGND VGND VPWR VPWR sky130_fd_sc_hd__fill_1
XFILLER_67_440 VGND VGND VPWR VPWR sky130_fd_sc_hd__fill_2
X_4196_ _7391_/Q _4261_/A2 _5080_/S _7295_/Q _4195_/X VGND VGND VPWR VPWR _4196_/X
+ sky130_fd_sc_hd__a221o_2
XFILLER_27_326 VGND VGND VPWR VPWR sky130_fd_sc_hd__decap_3
XFILLER_55_635 VGND VGND VPWR VPWR sky130_fd_sc_hd__decap_3
XFILLER_67_495 VGND VGND VPWR VPWR sky130_fd_sc_hd__decap_3
XFILLER_27_359 VGND VGND VPWR VPWR sky130_fd_sc_hd__fill_1
XFILLER_55_668 VGND VGND VPWR VPWR sky130_fd_sc_hd__decap_3
XFILLER_82_421 VGND VGND VPWR VPWR sky130_fd_sc_hd__decap_3
XFILLER_54_167 VGND VGND VPWR VPWR sky130_fd_sc_hd__fill_1
XFILLER_55_679 VGND VGND VPWR VPWR sky130_fd_sc_hd__decap_3
XFILLER_70_616 VGND VGND VPWR VPWR sky130_fd_sc_hd__decap_3
X_6906_ clkload6/A _6906_/D VGND VGND VPWR VPWR _6906_/Q sky130_fd_sc_hd__dfxtp_2
XTAP_TAPCELL_ROW_85_1271 VGND VPWR sky130_fd_sc_hd__tapvpwrvgnd_1
XTAP_TAPCELL_ROW_25_549 VGND VPWR sky130_fd_sc_hd__tapvpwrvgnd_1
XFILLER_23_543 VGND VGND VPWR VPWR sky130_fd_sc_hd__decap_3
X_6837_ clkload9/A _6837_/D VGND VGND VPWR VPWR _6837_/Q sky130_fd_sc_hd__dfxtp_2
XFILLER_10_215 VGND VGND VPWR VPWR sky130_fd_sc_hd__decap_3
XFILLER_23_576 VGND VGND VPWR VPWR sky130_fd_sc_hd__decap_3
XFILLER_109_615 VGND VGND VPWR VPWR sky130_fd_sc_hd__fill_1
X_6768_ _6974_/CLK _6768_/D VGND VGND VPWR VPWR _6768_/Q sky130_fd_sc_hd__dfxtp_2
XFILLER_109_626 VGND VGND VPWR VPWR sky130_fd_sc_hd__decap_3
X_6699_ _7311_/CLK _6699_/D VGND VGND VPWR VPWR _6699_/Q sky130_fd_sc_hd__dfxtp_2
X_5719_ _7365_/Q hold922/X _5735_/S VGND VGND VPWR VPWR _6709_/D sky130_fd_sc_hd__mux2_2
XFILLER_109_659 VGND VGND VPWR VPWR sky130_fd_sc_hd__decap_3
XFILLER_116_191 VGND VGND VPWR VPWR sky130_fd_sc_hd__decap_3
XFILLER_104_342 VGND VGND VPWR VPWR sky130_fd_sc_hd__fill_2
XFILLER_2_458 VGND VGND VPWR VPWR sky130_fd_sc_hd__decap_3
XFILLER_1_18 VGND VGND VPWR VPWR sky130_fd_sc_hd__decap_3
XFILLER_77_259 VGND VGND VPWR VPWR sky130_fd_sc_hd__decap_3
XFILLER_100_581 VGND VGND VPWR VPWR sky130_fd_sc_hd__decap_3
XFILLER_105_72 VGND VGND VPWR VPWR sky130_fd_sc_hd__fill_1
XFILLER_46_613 VGND VGND VPWR VPWR sky130_fd_sc_hd__decap_3
XFILLER_58_473 VGND VGND VPWR VPWR sky130_fd_sc_hd__decap_3
XFILLER_65_21 VGND VGND VPWR VPWR sky130_fd_sc_hd__decap_3
XFILLER_92_218 VGND VGND VPWR VPWR sky130_fd_sc_hd__decap_3
XFILLER_100_592 VGND VGND VPWR VPWR sky130_fd_sc_hd__decap_3
XFILLER_18_337 VGND VGND VPWR VPWR sky130_fd_sc_hd__fill_2
XFILLER_18_348 VGND VGND VPWR VPWR sky130_fd_sc_hd__decap_3
XFILLER_46_657 VGND VGND VPWR VPWR sky130_fd_sc_hd__decap_3
XFILLER_85_281 VGND VGND VPWR VPWR sky130_fd_sc_hd__decap_3
XFILLER_45_156 VGND VGND VPWR VPWR sky130_fd_sc_hd__fill_2
XFILLER_45_178 VGND VGND VPWR VPWR sky130_fd_sc_hd__decap_3
XFILLER_26_392 VGND VGND VPWR VPWR sky130_fd_sc_hd__decap_3
XFILLER_54_690 VGND VGND VPWR VPWR sky130_fd_sc_hd__fill_1
XFILLER_61_638 VGND VGND VPWR VPWR sky130_fd_sc_hd__decap_3
XFILLER_81_20 VGND VGND VPWR VPWR sky130_fd_sc_hd__decap_3
XFILLER_14_554 VGND VGND VPWR VPWR sky130_fd_sc_hd__decap_3
XFILLER_41_351 VGND VGND VPWR VPWR sky130_fd_sc_hd__decap_3
XFILLER_14_587 VGND VGND VPWR VPWR sky130_fd_sc_hd__fill_1
XFILLER_14_598 VGND VGND VPWR VPWR sky130_fd_sc_hd__decap_3
XFILLER_41_373 VGND VGND VPWR VPWR sky130_fd_sc_hd__decap_3
XTAP_TAPCELL_ROW_52_880 VGND VPWR sky130_fd_sc_hd__tapvpwrvgnd_1
XFILLER_108_681 VGND VGND VPWR VPWR sky130_fd_sc_hd__decap_3
XFILLER_114_106 VGND VGND VPWR VPWR sky130_fd_sc_hd__decap_3
XFILLER_115_629 VGND VGND VPWR VPWR sky130_fd_sc_hd__decap_3
XFILLER_68_215 VGND VGND VPWR VPWR sky130_fd_sc_hd__decap_3
XFILLER_96_524 VGND VGND VPWR VPWR sky130_fd_sc_hd__decap_3
XFILLER_96_557 VGND VGND VPWR VPWR sky130_fd_sc_hd__decap_3
X_4050_ _7053_/Q _4488_/S _4406_/A2 _7405_/Q _4049_/X VGND VGND VPWR VPWR _4050_/X
+ sky130_fd_sc_hd__a221o_2
XFILLER_83_207 VGND VGND VPWR VPWR sky130_fd_sc_hd__decap_3
XFILLER_37_635 VGND VGND VPWR VPWR sky130_fd_sc_hd__decap_3
XFILLER_37_668 VGND VGND VPWR VPWR sky130_fd_sc_hd__decap_3
XFILLER_64_421 VGND VGND VPWR VPWR sky130_fd_sc_hd__decap_3
XFILLER_64_432 VGND VGND VPWR VPWR sky130_fd_sc_hd__decap_3
XFILLER_76_292 VGND VGND VPWR VPWR sky130_fd_sc_hd__decap_3
XTAP_TAPCELL_ROW_108_1547 VGND VPWR sky130_fd_sc_hd__tapvpwrvgnd_1
XFILLER_24_307 VGND VGND VPWR VPWR sky130_fd_sc_hd__fill_1
XFILLER_37_679 VGND VGND VPWR VPWR sky130_fd_sc_hd__decap_3
XFILLER_52_616 VGND VGND VPWR VPWR sky130_fd_sc_hd__decap_3
XFILLER_24_329 VGND VGND VPWR VPWR sky130_fd_sc_hd__decap_3
X_4952_ _4967_/B _4968_/A VGND VGND VPWR VPWR _4969_/C sky130_fd_sc_hd__or2b_2
XFILLER_60_660 VGND VGND VPWR VPWR sky130_fd_sc_hd__decap_3
X_3903_ _6782_/Q _3903_/A2 _3903_/B1 _6692_/Q _3902_/X VGND VGND VPWR VPWR _3904_/B
+ sky130_fd_sc_hd__a221o_2
X_6622_ _6622_/A VGND VGND VPWR VPWR _6622_/Y sky130_fd_sc_hd__inv_2
XTAP_TAPCELL_ROW_22_519 VGND VPWR sky130_fd_sc_hd__tapvpwrvgnd_1
XFILLER_20_557 VGND VGND VPWR VPWR sky130_fd_sc_hd__decap_3
X_6553_ _6651_/A VGND VGND VPWR VPWR _6553_/Y sky130_fd_sc_hd__inv_2
X_3765_ _3629_/Y _3764_/X _3833_/S VGND VGND VPWR VPWR _4927_/B sky130_fd_sc_hd__o21a_2
XFILLER_106_607 VGND VGND VPWR VPWR sky130_fd_sc_hd__decap_3
X_6484_ _6643_/A VGND VGND VPWR VPWR _6484_/Y sky130_fd_sc_hd__inv_2
X_3696_ _6940_/Q _3768_/A2 _3918_/B1 _6804_/Q _3695_/X VGND VGND VPWR VPWR _3696_/X
+ sky130_fd_sc_hd__a221o_2
XFILLER_9_591 VGND VGND VPWR VPWR sky130_fd_sc_hd__decap_3
XFILLER_10_49 VGND VGND VPWR VPWR sky130_fd_sc_hd__fill_1
XFILLER_114_640 VGND VGND VPWR VPWR sky130_fd_sc_hd__decap_3
XFILLER_114_651 VGND VGND VPWR VPWR sky130_fd_sc_hd__decap_3
XFILLER_59_204 VGND VGND VPWR VPWR sky130_fd_sc_hd__decap_3
XFILLER_99_340 VGND VGND VPWR VPWR sky130_fd_sc_hd__fill_1
XFILLER_114_684 VGND VGND VPWR VPWR sky130_fd_sc_hd__decap_3
XFILLER_59_237 VGND VGND VPWR VPWR sky130_fd_sc_hd__decap_3
XFILLER_87_513 VGND VGND VPWR VPWR sky130_fd_sc_hd__fill_1
XFILLER_87_546 VGND VGND VPWR VPWR sky130_fd_sc_hd__decap_3
X_7105_ _7368_/CLK _7105_/D _6385_/Y VGND VGND VPWR VPWR _7105_/Q sky130_fd_sc_hd__dfrtp_2
X_4317_ _7322_/Q _3975_/S _4346_/B1 _7354_/Q _4248_/A VGND VGND VPWR VPWR _4317_/X
+ sky130_fd_sc_hd__a221o_2
XFILLER_19_47 VGND VGND VPWR VPWR sky130_fd_sc_hd__fill_1
XFILLER_59_248 VGND VGND VPWR VPWR sky130_fd_sc_hd__decap_3
XFILLER_87_579 VGND VGND VPWR VPWR sky130_fd_sc_hd__decap_3
X_7036_ _7344_/CLK _7036_/D _6316_/Y VGND VGND VPWR VPWR _7036_/Q sky130_fd_sc_hd__dfrtp_2
X_4248_ _4248_/A _4248_/B _4248_/C VGND VGND VPWR VPWR _4626_/B sky130_fd_sc_hd__or3_4
XFILLER_27_101 VGND VGND VPWR VPWR sky130_fd_sc_hd__decap_3
XFILLER_28_613 VGND VGND VPWR VPWR sky130_fd_sc_hd__decap_3
XFILLER_74_218 VGND VGND VPWR VPWR sky130_fd_sc_hd__decap_3
XTAP_TAPCELL_ROW_87_1300 VGND VPWR sky130_fd_sc_hd__tapvpwrvgnd_1
XFILLER_28_657 VGND VGND VPWR VPWR sky130_fd_sc_hd__decap_3
XFILLER_55_421 VGND VGND VPWR VPWR sky130_fd_sc_hd__decap_3
XFILLER_67_281 VGND VGND VPWR VPWR sky130_fd_sc_hd__decap_3
X_4179_ _4173_/Y _4248_/A _4376_/A _4178_/Y VGND VGND VPWR VPWR _4186_/A sky130_fd_sc_hd__a211o_2
XFILLER_70_402 VGND VGND VPWR VPWR sky130_fd_sc_hd__decap_3
XFILLER_82_251 VGND VGND VPWR VPWR sky130_fd_sc_hd__fill_1
XTAP_TAPCELL_ROW_2_277 VGND VPWR sky130_fd_sc_hd__tapvpwrvgnd_1
XFILLER_36_690 VGND VGND VPWR VPWR sky130_fd_sc_hd__fill_1
XFILLER_42_115 VGND VGND VPWR VPWR sky130_fd_sc_hd__fill_2
XFILLER_42_126 VGND VGND VPWR VPWR sky130_fd_sc_hd__fill_2
XFILLER_43_638 VGND VGND VPWR VPWR sky130_fd_sc_hd__decap_3
XFILLER_51_671 VGND VGND VPWR VPWR sky130_fd_sc_hd__fill_1
XFILLER_51_682 VGND VGND VPWR VPWR sky130_fd_sc_hd__decap_3
XFILLER_11_535 VGND VGND VPWR VPWR sky130_fd_sc_hd__decap_3
Xclkbuf_3_3__f_clk clkbuf_0_clk/X VGND VGND VPWR VPWR clkload2/A sky130_fd_sc_hd__clkbuf_16
XPHY_EDGE_ROW_14_Right_14 VGND VGND VPWR VPWR sky130_fd_sc_hd__decap_3
XFILLER_109_423 VGND VGND VPWR VPWR sky130_fd_sc_hd__decap_3
XFILLER_11_579 VGND VGND VPWR VPWR sky130_fd_sc_hd__decap_3
XFILLER_7_517 VGND VGND VPWR VPWR sky130_fd_sc_hd__decap_3
XFILLER_109_467 VGND VGND VPWR VPWR sky130_fd_sc_hd__decap_3
XFILLER_2_200 VGND VGND VPWR VPWR sky130_fd_sc_hd__decap_3
XFILLER_105_662 VGND VGND VPWR VPWR sky130_fd_sc_hd__decap_3
XFILLER_105_673 VGND VGND VPWR VPWR sky130_fd_sc_hd__decap_3
XFILLER_116_60 VGND VGND VPWR VPWR sky130_fd_sc_hd__decap_3
XFILLER_2_266 VGND VGND VPWR VPWR sky130_fd_sc_hd__fill_1
XFILLER_78_524 VGND VGND VPWR VPWR sky130_fd_sc_hd__fill_1
XPHY_EDGE_ROW_23_Right_23 VGND VGND VPWR VPWR sky130_fd_sc_hd__decap_3
XFILLER_78_557 VGND VGND VPWR VPWR sky130_fd_sc_hd__decap_3
XFILLER_93_505 VGND VGND VPWR VPWR sky130_fd_sc_hd__decap_3
XFILLER_76_64 VGND VGND VPWR VPWR sky130_fd_sc_hd__fill_2
XFILLER_93_538 VGND VGND VPWR VPWR sky130_fd_sc_hd__decap_3
XFILLER_18_101 VGND VGND VPWR VPWR sky130_fd_sc_hd__decap_3
XFILLER_19_635 VGND VGND VPWR VPWR sky130_fd_sc_hd__decap_3
XFILLER_58_270 VGND VGND VPWR VPWR sky130_fd_sc_hd__decap_3
XFILLER_19_668 VGND VGND VPWR VPWR sky130_fd_sc_hd__decap_3
XFILLER_19_679 VGND VGND VPWR VPWR sky130_fd_sc_hd__decap_3
XFILLER_34_616 VGND VGND VPWR VPWR sky130_fd_sc_hd__decap_3
XFILLER_18_189 VGND VGND VPWR VPWR sky130_fd_sc_hd__fill_2
XFILLER_61_413 VGND VGND VPWR VPWR sky130_fd_sc_hd__fill_2
XFILLER_73_284 VGND VGND VPWR VPWR sky130_fd_sc_hd__decap_3
XPHY_EDGE_ROW_32_Right_32 VGND VGND VPWR VPWR sky130_fd_sc_hd__decap_3
XFILLER_14_351 VGND VGND VPWR VPWR sky130_fd_sc_hd__fill_2
XFILLER_14_362 VGND VGND VPWR VPWR sky130_fd_sc_hd__fill_2
XFILLER_42_660 VGND VGND VPWR VPWR sky130_fd_sc_hd__decap_3
XFILLER_41_192 VGND VGND VPWR VPWR sky130_fd_sc_hd__fill_2
XTAP_TAPCELL_ROW_103_1488 VGND VPWR sky130_fd_sc_hd__tapvpwrvgnd_1
X_3550_ _4614_/A _3547_/A _3547_/B _3548_/X VGND VGND VPWR VPWR _3550_/X sky130_fd_sc_hd__a31o_2
XFILLER_6_572 VGND VGND VPWR VPWR sky130_fd_sc_hd__decap_3
XFILLER_115_426 VGND VGND VPWR VPWR sky130_fd_sc_hd__decap_3
X_3481_ _7344_/Q _4337_/B _5157_/S _7280_/Q VGND VGND VPWR VPWR _3482_/C sky130_fd_sc_hd__a22o_2
XFILLER_102_109 VGND VGND VPWR VPWR sky130_fd_sc_hd__decap_3
XFILLER_44_3 VGND VGND VPWR VPWR sky130_fd_sc_hd__fill_1
XFILLER_69_502 VGND VGND VPWR VPWR sky130_fd_sc_hd__fill_2
XTAP_TAPCELL_ROW_71_1101 VGND VPWR sky130_fd_sc_hd__tapvpwrvgnd_1
XPHY_EDGE_ROW_41_Right_41 VGND VGND VPWR VPWR sky130_fd_sc_hd__decap_3
XFILLER_69_535 VGND VGND VPWR VPWR sky130_fd_sc_hd__decap_3
X_5151_ _5151_/A _5659_/B VGND VGND VPWR VPWR _5151_/X sky130_fd_sc_hd__or2_2
XFILLER_111_632 VGND VGND VPWR VPWR sky130_fd_sc_hd__decap_3
XFILLER_111_665 VGND VGND VPWR VPWR sky130_fd_sc_hd__decap_3
XFILLER_69_579 VGND VGND VPWR VPWR sky130_fd_sc_hd__decap_3
X_5082_ _6986_/Q _5098_/A VGND VGND VPWR VPWR _6986_/D sky130_fd_sc_hd__xor2_2
X_4102_ _7077_/Q _4102_/B VGND VGND VPWR VPWR _4141_/B sky130_fd_sc_hd__nor2_2
XFILLER_110_164 VGND VGND VPWR VPWR sky130_fd_sc_hd__decap_3
XFILLER_111_676 VGND VGND VPWR VPWR sky130_fd_sc_hd__decap_3
XFILLER_96_365 VGND VGND VPWR VPWR sky130_fd_sc_hd__fill_1
X_4033_ _7054_/Q _4478_/S _4406_/A2 _7406_/Q VGND VGND VPWR VPWR _4033_/X sky130_fd_sc_hd__a22o_2
XFILLER_110_197 VGND VGND VPWR VPWR sky130_fd_sc_hd__fill_2
XFILLER_37_410 VGND VGND VPWR VPWR sky130_fd_sc_hd__decap_3
XFILLER_49_281 VGND VGND VPWR VPWR sky130_fd_sc_hd__fill_2
XFILLER_112_18 VGND VGND VPWR VPWR sky130_fd_sc_hd__decap_3
XFILLER_112_29 VGND VGND VPWR VPWR sky130_fd_sc_hd__decap_3
XFILLER_52_402 VGND VGND VPWR VPWR sky130_fd_sc_hd__decap_3
XFILLER_64_240 VGND VGND VPWR VPWR sky130_fd_sc_hd__decap_3
XFILLER_92_560 VGND VGND VPWR VPWR sky130_fd_sc_hd__decap_3
XTAP_TAPCELL_ROW_55_909 VGND VPWR sky130_fd_sc_hd__tapvpwrvgnd_1
XFILLER_18_690 VGND VGND VPWR VPWR sky130_fd_sc_hd__fill_1
XFILLER_25_638 VGND VGND VPWR VPWR sky130_fd_sc_hd__decap_3
XFILLER_52_424 VGND VGND VPWR VPWR sky130_fd_sc_hd__decap_3
XFILLER_64_262 VGND VGND VPWR VPWR sky130_fd_sc_hd__decap_3
XFILLER_64_295 VGND VGND VPWR VPWR sky130_fd_sc_hd__decap_3
XTAP_TAPCELL_ROW_69_1085 VGND VPWR sky130_fd_sc_hd__tapvpwrvgnd_1
XTAP_TAPCELL_ROW_69_1074 VGND VPWR sky130_fd_sc_hd__tapvpwrvgnd_1
XPHY_EDGE_ROW_50_Right_50 VGND VGND VPWR VPWR sky130_fd_sc_hd__decap_3
XFILLER_24_159 VGND VGND VPWR VPWR sky130_fd_sc_hd__decap_3
XFILLER_52_457 VGND VGND VPWR VPWR sky130_fd_sc_hd__decap_3
XTAP_TAPCELL_ROW_82_1241 VGND VPWR sky130_fd_sc_hd__tapvpwrvgnd_1
XTAP_TAPCELL_ROW_82_1230 VGND VPWR sky130_fd_sc_hd__tapvpwrvgnd_1
XFILLER_33_671 VGND VGND VPWR VPWR sky130_fd_sc_hd__fill_1
XFILLER_33_682 VGND VGND VPWR VPWR sky130_fd_sc_hd__decap_3
XFILLER_40_619 VGND VGND VPWR VPWR sky130_fd_sc_hd__decap_3
X_4935_ _6995_/Q _4963_/A VGND VGND VPWR VPWR _6995_/D sky130_fd_sc_hd__xor2_2
XTAP_TAPCELL_ROW_35_677 VGND VPWR sky130_fd_sc_hd__tapvpwrvgnd_1
XTAP_TAPCELL_ROW_35_666 VGND VPWR sky130_fd_sc_hd__tapvpwrvgnd_1
XANTENNA_11 _5633_/B VGND VGND VPWR VPWR sky130_fd_sc_hd__diode_2
XFILLER_32_181 VGND VGND VPWR VPWR sky130_fd_sc_hd__decap_3
X_6605_ _6633_/A VGND VGND VPWR VPWR _6605_/Y sky130_fd_sc_hd__inv_2
X_4797_ _4970_/A1 _4648_/A _4397_/Y _5033_/B2 VGND VGND VPWR VPWR _4797_/X sky130_fd_sc_hd__a22o_2
X_3817_ _3682_/A _3816_/X _4791_/A1 VGND VGND VPWR VPWR _3817_/X sky130_fd_sc_hd__a21o_2
X_6536_ _6624_/A VGND VGND VPWR VPWR _6536_/Y sky130_fd_sc_hd__inv_2
X_3748_ _3735_/X _3738_/X _3740_/X _3629_/A _3747_/X VGND VGND VPWR VPWR _3748_/X
+ sky130_fd_sc_hd__a221o_2
XFILLER_115_9 VGND VGND VPWR VPWR sky130_fd_sc_hd__decap_3
XFILLER_106_448 VGND VGND VPWR VPWR sky130_fd_sc_hd__decap_3
X_6467_ _6625_/A VGND VGND VPWR VPWR _6467_/Y sky130_fd_sc_hd__inv_2
X_3679_ _6894_/Q VGND VGND VPWR VPWR _3679_/Y sky130_fd_sc_hd__inv_2
X_6398_ _6622_/A VGND VGND VPWR VPWR _6398_/Y sky130_fd_sc_hd__inv_2
XTAP_TAPCELL_ROW_93_1370 VGND VPWR sky130_fd_sc_hd__tapvpwrvgnd_1
XFILLER_102_610 VGND VGND VPWR VPWR sky130_fd_sc_hd__decap_3
XTAP_TAPCELL_ROW_7_336 VGND VPWR sky130_fd_sc_hd__tapvpwrvgnd_1
XFILLER_101_131 VGND VGND VPWR VPWR sky130_fd_sc_hd__decap_3
XFILLER_102_643 VGND VGND VPWR VPWR sky130_fd_sc_hd__fill_1
XFILLER_102_654 VGND VGND VPWR VPWR sky130_fd_sc_hd__decap_3
XFILLER_114_492 VGND VGND VPWR VPWR sky130_fd_sc_hd__decap_3
XFILLER_87_343 VGND VGND VPWR VPWR sky130_fd_sc_hd__decap_3
XFILLER_101_164 VGND VGND VPWR VPWR sky130_fd_sc_hd__fill_1
XFILLER_102_687 VGND VGND VPWR VPWR sky130_fd_sc_hd__decap_3
XFILLER_101_175 VGND VGND VPWR VPWR sky130_fd_sc_hd__decap_3
XFILLER_101_186 VGND VGND VPWR VPWR sky130_fd_sc_hd__decap_3
XFILLER_28_421 VGND VGND VPWR VPWR sky130_fd_sc_hd__decap_3
XFILLER_75_538 VGND VGND VPWR VPWR sky130_fd_sc_hd__decap_3
X_7019_ _7406_/CLK _7019_/D _6299_/Y VGND VGND VPWR VPWR _7019_/Q sky130_fd_sc_hd__dfrtp_2
XFILLER_16_616 VGND VGND VPWR VPWR sky130_fd_sc_hd__decap_3
XFILLER_55_284 VGND VGND VPWR VPWR sky130_fd_sc_hd__decap_3
XFILLER_83_582 VGND VGND VPWR VPWR sky130_fd_sc_hd__decap_3
XFILLER_102_40 VGND VGND VPWR VPWR sky130_fd_sc_hd__fill_1
XFILLER_102_73 VGND VGND VPWR VPWR sky130_fd_sc_hd__decap_3
XFILLER_43_446 VGND VGND VPWR VPWR sky130_fd_sc_hd__fill_2
XFILLER_70_232 VGND VGND VPWR VPWR sky130_fd_sc_hd__decap_3
XFILLER_24_660 VGND VGND VPWR VPWR sky130_fd_sc_hd__decap_3
XFILLER_70_287 VGND VGND VPWR VPWR sky130_fd_sc_hd__decap_3
XFILLER_23_192 VGND VGND VPWR VPWR sky130_fd_sc_hd__decap_3
XFILLER_11_343 VGND VGND VPWR VPWR sky130_fd_sc_hd__decap_3
XFILLER_7_28 VGND VGND VPWR VPWR sky130_fd_sc_hd__decap_3
XFILLER_109_231 VGND VGND VPWR VPWR sky130_fd_sc_hd__decap_3
XFILLER_7_369 VGND VGND VPWR VPWR sky130_fd_sc_hd__decap_3
XFILLER_3_520 VGND VGND VPWR VPWR sky130_fd_sc_hd__decap_3
XFILLER_3_553 VGND VGND VPWR VPWR sky130_fd_sc_hd__decap_3
XFILLER_3_564 VGND VGND VPWR VPWR sky130_fd_sc_hd__decap_3
XFILLER_98_619 VGND VGND VPWR VPWR sky130_fd_sc_hd__decap_3
XFILLER_112_418 VGND VGND VPWR VPWR sky130_fd_sc_hd__fill_2
XFILLER_3_597 VGND VGND VPWR VPWR sky130_fd_sc_hd__decap_3
XFILLER_97_129 VGND VGND VPWR VPWR sky130_fd_sc_hd__decap_3
XFILLER_105_492 VGND VGND VPWR VPWR sky130_fd_sc_hd__decap_3
XFILLER_78_321 VGND VGND VPWR VPWR sky130_fd_sc_hd__decap_3
XFILLER_78_365 VGND VGND VPWR VPWR sky130_fd_sc_hd__decap_3
XFILLER_38_229 VGND VGND VPWR VPWR sky130_fd_sc_hd__fill_1
XFILLER_93_335 VGND VGND VPWR VPWR sky130_fd_sc_hd__fill_1
XFILLER_19_465 VGND VGND VPWR VPWR sky130_fd_sc_hd__decap_3
XFILLER_46_240 VGND VGND VPWR VPWR sky130_fd_sc_hd__decap_3
XFILLER_74_560 VGND VGND VPWR VPWR sky130_fd_sc_hd__decap_3
XFILLER_46_284 VGND VGND VPWR VPWR sky130_fd_sc_hd__decap_3
XTAP_TAPCELL_ROW_105_1517 VGND VPWR sky130_fd_sc_hd__tapvpwrvgnd_1
XTAP_TAPCELL_ROW_105_1506 VGND VPWR sky130_fd_sc_hd__tapvpwrvgnd_1
XFILLER_15_671 VGND VGND VPWR VPWR sky130_fd_sc_hd__fill_1
XFILLER_15_682 VGND VGND VPWR VPWR sky130_fd_sc_hd__decap_3
XFILLER_22_619 VGND VGND VPWR VPWR sky130_fd_sc_hd__decap_3
XFILLER_61_287 VGND VGND VPWR VPWR sky130_fd_sc_hd__decap_3
Xclkbuf_leaf_41_clk clkbuf_leaf_1_clk/A VGND VGND VPWR VPWR clkload9/A sky130_fd_sc_hd__clkbuf_16
X_4720_ _4720_/A _4720_/B VGND VGND VPWR VPWR _4720_/X sky130_fd_sc_hd__xor2_2
XTAP_TAPCELL_ROW_32_636 VGND VPWR sky130_fd_sc_hd__tapvpwrvgnd_1
XFILLER_30_663 VGND VGND VPWR VPWR sky130_fd_sc_hd__decap_3
X_4651_ _4813_/A _4810_/B VGND VGND VPWR VPWR _4652_/B sky130_fd_sc_hd__and2_2
XTAP_TAPCELL_ROW_60_967 VGND VPWR sky130_fd_sc_hd__tapvpwrvgnd_1
X_3602_ _4614_/A _3547_/A _3547_/B _4614_/C _4613_/B VGND VGND VPWR VPWR _3603_/B
+ sky130_fd_sc_hd__a41o_2
X_7370_ _7374_/CLK _7370_/D _6650_/Y VGND VGND VPWR VPWR _7370_/Q sky130_fd_sc_hd__dfrtp_2
XTAP_TAPCELL_ROW_12_393 VGND VPWR sky130_fd_sc_hd__tapvpwrvgnd_1
Xhold804 _6880_/Q VGND VGND VPWR VPWR _6880_/D sky130_fd_sc_hd__dlygate4sd3_1
Xhold815 _6875_/Q VGND VGND VPWR VPWR _6875_/D sky130_fd_sc_hd__dlygate4sd3_1
Xhold826 _6763_/Q VGND VGND VPWR VPWR _6763_/D sky130_fd_sc_hd__dlygate4sd3_1
Xhold837 _6928_/Q VGND VGND VPWR VPWR _6928_/D sky130_fd_sc_hd__dlygate4sd3_1
X_6321_ _6673_/A VGND VGND VPWR VPWR _6321_/Y sky130_fd_sc_hd__inv_2
XTAP_TAPCELL_ROW_116_1657 VGND VPWR sky130_fd_sc_hd__tapvpwrvgnd_1
XTAP_TAPCELL_ROW_116_1646 VGND VPWR sky130_fd_sc_hd__tapvpwrvgnd_1
XFILLER_107_18 VGND VGND VPWR VPWR sky130_fd_sc_hd__decap_3
Xhold848 _7069_/Q VGND VGND VPWR VPWR _7069_/D sky130_fd_sc_hd__dlygate4sd3_1
Xhold859 _7117_/Q VGND VGND VPWR VPWR _7117_/D sky130_fd_sc_hd__dlygate4sd3_1
Xmax_cap567 _3380_/Y VGND VGND VPWR VPWR _4285_/B1 sky130_fd_sc_hd__buf_2
Xmax_cap556 _4275_/Y VGND VGND VPWR VPWR _4987_/A sky130_fd_sc_hd__buf_2
XFILLER_115_278 VGND VGND VPWR VPWR sky130_fd_sc_hd__fill_2
XFILLER_88_118 VGND VGND VPWR VPWR sky130_fd_sc_hd__decap_3
X_5203_ _5203_/A _5209_/B VGND VGND VPWR VPWR _7227_/D sky130_fd_sc_hd__and2_2
XFILLER_69_321 VGND VGND VPWR VPWR sky130_fd_sc_hd__fill_1
X_5134_ _3735_/A _3908_/X _3346_/A VGND VGND VPWR VPWR _5134_/X sky130_fd_sc_hd__o21a_2
X_3395_ _7059_/Q _3577_/B VGND VGND VPWR VPWR _3589_/B sky130_fd_sc_hd__nor2_2
XFILLER_97_641 VGND VGND VPWR VPWR sky130_fd_sc_hd__decap_3
XFILLER_111_473 VGND VGND VPWR VPWR sky130_fd_sc_hd__decap_3
XFILLER_96_162 VGND VGND VPWR VPWR sky130_fd_sc_hd__decap_3
XFILLER_97_685 VGND VGND VPWR VPWR sky130_fd_sc_hd__decap_3
X_5065_ _6986_/Q _5098_/A _6987_/Q VGND VGND VPWR VPWR _5066_/B sky130_fd_sc_hd__a21oi_2
XFILLER_84_379 VGND VGND VPWR VPWR sky130_fd_sc_hd__decap_3
XFILLER_37_262 VGND VGND VPWR VPWR sky130_fd_sc_hd__decap_3
XFILLER_37_284 VGND VGND VPWR VPWR sky130_fd_sc_hd__decap_3
XFILLER_65_582 VGND VGND VPWR VPWR sky130_fd_sc_hd__decap_3
XFILLER_25_435 VGND VGND VPWR VPWR sky130_fd_sc_hd__fill_1
XFILLER_37_295 VGND VGND VPWR VPWR sky130_fd_sc_hd__decap_3
XFILLER_80_563 VGND VGND VPWR VPWR sky130_fd_sc_hd__decap_3
Xclkbuf_leaf_32_clk clkload1/A VGND VGND VPWR VPWR _7317_/CLK sky130_fd_sc_hd__clkbuf_16
X_4918_ _4918_/A _4918_/B VGND VGND VPWR VPWR _4936_/B sky130_fd_sc_hd__nor2_2
XFILLER_21_641 VGND VGND VPWR VPWR sky130_fd_sc_hd__decap_3
XFILLER_21_685 VGND VGND VPWR VPWR sky130_fd_sc_hd__decap_3
X_4849_ _4872_/A _4872_/B VGND VGND VPWR VPWR _4849_/Y sky130_fd_sc_hd__nor2_2
XFILLER_20_195 VGND VGND VPWR VPWR sky130_fd_sc_hd__fill_1
X_6519_ _6617_/A VGND VGND VPWR VPWR _6519_/Y sky130_fd_sc_hd__inv_2
XFILLER_106_256 VGND VGND VPWR VPWR sky130_fd_sc_hd__fill_2
XFILLER_0_578 VGND VGND VPWR VPWR sky130_fd_sc_hd__fill_1
XFILLER_0_589 VGND VGND VPWR VPWR sky130_fd_sc_hd__decap_3
XFILLER_102_462 VGND VGND VPWR VPWR sky130_fd_sc_hd__decap_3
XFILLER_48_505 VGND VGND VPWR VPWR sky130_fd_sc_hd__fill_2
XFILLER_57_11 VGND VGND VPWR VPWR sky130_fd_sc_hd__decap_3
XFILLER_75_302 VGND VGND VPWR VPWR sky130_fd_sc_hd__decap_3
XFILLER_87_151 VGND VGND VPWR VPWR sky130_fd_sc_hd__fill_2
XFILLER_88_663 VGND VGND VPWR VPWR sky130_fd_sc_hd__decap_3
XFILLER_102_495 VGND VGND VPWR VPWR sky130_fd_sc_hd__decap_3
XFILLER_87_184 VGND VGND VPWR VPWR sky130_fd_sc_hd__decap_3
XFILLER_113_50 VGND VGND VPWR VPWR sky130_fd_sc_hd__decap_3
XFILLER_113_72 VGND VGND VPWR VPWR sky130_fd_sc_hd__decap_3
XFILLER_16_402 VGND VGND VPWR VPWR sky130_fd_sc_hd__decap_3
XFILLER_28_251 VGND VGND VPWR VPWR sky130_fd_sc_hd__fill_1
XFILLER_28_262 VGND VGND VPWR VPWR sky130_fd_sc_hd__decap_3
XFILLER_28_284 VGND VGND VPWR VPWR sky130_fd_sc_hd__decap_3
XFILLER_56_582 VGND VGND VPWR VPWR sky130_fd_sc_hd__decap_3
XFILLER_16_446 VGND VGND VPWR VPWR sky130_fd_sc_hd__fill_1
XFILLER_43_221 VGND VGND VPWR VPWR sky130_fd_sc_hd__decap_3
XFILLER_71_552 VGND VGND VPWR VPWR sky130_fd_sc_hd__decap_3
XFILLER_73_32 VGND VGND VPWR VPWR sky130_fd_sc_hd__decap_3
XFILLER_83_390 VGND VGND VPWR VPWR sky130_fd_sc_hd__fill_2
XFILLER_71_585 VGND VGND VPWR VPWR sky130_fd_sc_hd__decap_3
XFILLER_31_449 VGND VGND VPWR VPWR sky130_fd_sc_hd__decap_3
XFILLER_43_287 VGND VGND VPWR VPWR sky130_fd_sc_hd__decap_3
Xclkbuf_leaf_23_clk clkload5/A VGND VGND VPWR VPWR _7332_/CLK sky130_fd_sc_hd__clkbuf_16
XFILLER_12_663 VGND VGND VPWR VPWR sky130_fd_sc_hd__decap_3
XFILLER_8_601 VGND VGND VPWR VPWR sky130_fd_sc_hd__decap_3
XTAP_TAPCELL_ROW_100_1447 VGND VPWR sky130_fd_sc_hd__tapvpwrvgnd_1
XFILLER_8_634 VGND VGND VPWR VPWR sky130_fd_sc_hd__decap_3
XFILLER_8_645 VGND VGND VPWR VPWR sky130_fd_sc_hd__decap_3
XFILLER_8_678 VGND VGND VPWR VPWR sky130_fd_sc_hd__decap_3
XFILLER_7_199 VGND VGND VPWR VPWR sky130_fd_sc_hd__decap_3
XFILLER_112_248 VGND VGND VPWR VPWR sky130_fd_sc_hd__fill_1
XFILLER_112_259 VGND VGND VPWR VPWR sky130_fd_sc_hd__decap_3
XFILLER_79_641 VGND VGND VPWR VPWR sky130_fd_sc_hd__decap_3
XFILLER_66_302 VGND VGND VPWR VPWR sky130_fd_sc_hd__decap_3
XFILLER_78_162 VGND VGND VPWR VPWR sky130_fd_sc_hd__decap_3
XFILLER_79_685 VGND VGND VPWR VPWR sky130_fd_sc_hd__decap_3
XTAP_TAPCELL_ROW_111_1587 VGND VPWR sky130_fd_sc_hd__tapvpwrvgnd_1
XFILLER_39_549 VGND VGND VPWR VPWR sky130_fd_sc_hd__decap_3
XFILLER_66_335 VGND VGND VPWR VPWR sky130_fd_sc_hd__decap_3
XFILLER_93_121 VGND VGND VPWR VPWR sky130_fd_sc_hd__decap_3
XFILLER_94_622 VGND VGND VPWR VPWR sky130_fd_sc_hd__decap_3
XFILLER_81_305 VGND VGND VPWR VPWR sky130_fd_sc_hd__decap_3
XFILLER_94_666 VGND VGND VPWR VPWR sky130_fd_sc_hd__decap_3
XFILLER_19_273 VGND VGND VPWR VPWR sky130_fd_sc_hd__decap_3
XFILLER_19_284 VGND VGND VPWR VPWR sky130_fd_sc_hd__decap_3
XFILLER_47_582 VGND VGND VPWR VPWR sky130_fd_sc_hd__decap_3
XFILLER_34_232 VGND VGND VPWR VPWR sky130_fd_sc_hd__decap_3
X_6870_ _6968_/CLK _6870_/D VGND VGND VPWR VPWR _6870_/Q sky130_fd_sc_hd__dfxtp_2
XTAP_TAPCELL_ROW_66_1044 VGND VPWR sky130_fd_sc_hd__tapvpwrvgnd_1
XFILLER_22_416 VGND VGND VPWR VPWR sky130_fd_sc_hd__decap_3
XFILLER_34_276 VGND VGND VPWR VPWR sky130_fd_sc_hd__decap_3
XFILLER_62_563 VGND VGND VPWR VPWR sky130_fd_sc_hd__decap_3
XTAP_TAPCELL_ROW_17_452 VGND VPWR sky130_fd_sc_hd__tapvpwrvgnd_1
XFILLER_22_438 VGND VGND VPWR VPWR sky130_fd_sc_hd__decap_3
XTAP_TAPCELL_ROW_45_794 VGND VPWR sky130_fd_sc_hd__tapvpwrvgnd_1
Xclkbuf_leaf_14_clk clkload3/A VGND VGND VPWR VPWR _7307_/CLK sky130_fd_sc_hd__clkbuf_16
X_4703_ _6992_/Q _6993_/Q _5001_/A VGND VGND VPWR VPWR _4977_/A sky130_fd_sc_hd__and3_2
X_4634_ _4937_/A _4920_/A _4967_/B _4950_/A VGND VGND VPWR VPWR _4634_/Y sky130_fd_sc_hd__nand4bb_2
XFILLER_116_521 VGND VGND VPWR VPWR sky130_fd_sc_hd__decap_3
X_7353_ _7353_/CLK _7353_/D _6633_/Y VGND VGND VPWR VPWR _7353_/Q sky130_fd_sc_hd__dfrtp_2
Xhold601 _6755_/Q VGND VGND VPWR VPWR _6755_/D sky130_fd_sc_hd__dlygate4sd3_1
Xhold612 _6944_/Q VGND VGND VPWR VPWR _6944_/D sky130_fd_sc_hd__dlygate4sd3_1
X_4565_ _4565_/A _4577_/B VGND VGND VPWR VPWR _7298_/D sky130_fd_sc_hd__and2_2
XFILLER_116_543 VGND VGND VPWR VPWR sky130_fd_sc_hd__decap_3
XFILLER_89_405 VGND VGND VPWR VPWR sky130_fd_sc_hd__fill_1
Xhold623 _6748_/Q VGND VGND VPWR VPWR _6748_/D sky130_fd_sc_hd__dlygate4sd3_1
Xhold634 _6966_/Q VGND VGND VPWR VPWR _6966_/D sky130_fd_sc_hd__dlygate4sd3_1
Xhold645 _6878_/Q VGND VGND VPWR VPWR _6878_/D sky130_fd_sc_hd__dlygate4sd3_1
X_6304_ _6617_/A VGND VGND VPWR VPWR _6304_/Y sky130_fd_sc_hd__inv_2
X_3516_ _5118_/A _5129_/B _5118_/D _3371_/A VGND VGND VPWR VPWR _3516_/X sky130_fd_sc_hd__a211o_2
XTAP_TAPCELL_ROW_77_1173 VGND VPWR sky130_fd_sc_hd__tapvpwrvgnd_1
XFILLER_116_587 VGND VGND VPWR VPWR sky130_fd_sc_hd__fill_1
XFILLER_116_598 VGND VGND VPWR VPWR sky130_fd_sc_hd__fill_1
X_7284_ _7317_/CLK _7284_/D _6564_/Y VGND VGND VPWR VPWR _7284_/Q sky130_fd_sc_hd__dfrtp_2
Xhold656 _6947_/Q VGND VGND VPWR VPWR _6947_/D sky130_fd_sc_hd__dlygate4sd3_1
Xhold667 _6762_/Q VGND VGND VPWR VPWR _6762_/D sky130_fd_sc_hd__dlygate4sd3_1
Xhold678 _6792_/Q VGND VGND VPWR VPWR _6792_/D sky130_fd_sc_hd__dlygate4sd3_1
XPHY_EDGE_ROW_4_Right_4 VGND VGND VPWR VPWR sky130_fd_sc_hd__decap_3
XFILLER_89_449 VGND VGND VPWR VPWR sky130_fd_sc_hd__decap_3
Xhold689 _6881_/Q VGND VGND VPWR VPWR _6881_/D sky130_fd_sc_hd__dlygate4sd3_1
X_3447_ _7090_/Q _4335_/B1 _4351_/B1 _7122_/Q VGND VGND VPWR VPWR _3447_/X sky130_fd_sc_hd__a22o_2
XFILLER_103_259 VGND VGND VPWR VPWR sky130_fd_sc_hd__decap_3
XFILLER_57_302 VGND VGND VPWR VPWR sky130_fd_sc_hd__fill_2
XFILLER_69_151 VGND VGND VPWR VPWR sky130_fd_sc_hd__decap_3
XFILLER_85_600 VGND VGND VPWR VPWR sky130_fd_sc_hd__decap_3
XFILLER_97_460 VGND VGND VPWR VPWR sky130_fd_sc_hd__decap_3
X_3378_ _3378_/A _5646_/A VGND VGND VPWR VPWR _5229_/C sky130_fd_sc_hd__nor2_2
XFILLER_111_281 VGND VGND VPWR VPWR sky130_fd_sc_hd__decap_3
XFILLER_85_644 VGND VGND VPWR VPWR sky130_fd_sc_hd__decap_3
XFILLER_97_482 VGND VGND VPWR VPWR sky130_fd_sc_hd__decap_3
X_5117_ _5117_/A _5658_/D _3896_/Y VGND VGND VPWR VPWR _5117_/X sky130_fd_sc_hd__or3b_2
XFILLER_27_14 VGND VGND VPWR VPWR sky130_fd_sc_hd__fill_1
XFILLER_45_508 VGND VGND VPWR VPWR sky130_fd_sc_hd__decap_3
X_5048_ _4315_/Y _5085_/A2 _4621_/X VGND VGND VPWR VPWR _5073_/B sky130_fd_sc_hd__o21bai_2
XFILLER_38_560 VGND VGND VPWR VPWR sky130_fd_sc_hd__decap_3
XFILLER_85_688 VGND VGND VPWR VPWR sky130_fd_sc_hd__decap_3
XFILLER_25_221 VGND VGND VPWR VPWR sky130_fd_sc_hd__decap_3
XFILLER_25_243 VGND VGND VPWR VPWR sky130_fd_sc_hd__fill_2
XFILLER_25_254 VGND VGND VPWR VPWR sky130_fd_sc_hd__decap_3
XFILLER_53_585 VGND VGND VPWR VPWR sky130_fd_sc_hd__decap_3
XFILLER_13_449 VGND VGND VPWR VPWR sky130_fd_sc_hd__decap_3
XFILLER_80_371 VGND VGND VPWR VPWR sky130_fd_sc_hd__decap_3
XFILLER_80_393 VGND VGND VPWR VPWR sky130_fd_sc_hd__decap_3
X_6999_ _7144_/CLK _6999_/D _6279_/Y VGND VGND VPWR VPWR _6999_/Q sky130_fd_sc_hd__dfrtp_2
XFILLER_40_246 VGND VGND VPWR VPWR sky130_fd_sc_hd__decap_3
XFILLER_40_268 VGND VGND VPWR VPWR sky130_fd_sc_hd__decap_3
XFILLER_43_57 VGND VGND VPWR VPWR sky130_fd_sc_hd__fill_1
XFILLER_111_3 VGND VGND VPWR VPWR sky130_fd_sc_hd__decap_3
XFILLER_5_615 VGND VGND VPWR VPWR sky130_fd_sc_hd__fill_1
XFILLER_5_626 VGND VGND VPWR VPWR sky130_fd_sc_hd__decap_3
XFILLER_107_532 VGND VGND VPWR VPWR sky130_fd_sc_hd__decap_3
XFILLER_5_659 VGND VGND VPWR VPWR sky130_fd_sc_hd__decap_3
XFILLER_107_576 VGND VGND VPWR VPWR sky130_fd_sc_hd__decap_3
XFILLER_68_21 VGND VGND VPWR VPWR sky130_fd_sc_hd__decap_3
XFILLER_48_324 VGND VGND VPWR VPWR sky130_fd_sc_hd__decap_3
XFILLER_76_622 VGND VGND VPWR VPWR sky130_fd_sc_hd__decap_3
XFILLER_48_357 VGND VGND VPWR VPWR sky130_fd_sc_hd__decap_3
XFILLER_75_143 VGND VGND VPWR VPWR sky130_fd_sc_hd__decap_3
XFILLER_76_666 VGND VGND VPWR VPWR sky130_fd_sc_hd__decap_3
XFILLER_91_603 VGND VGND VPWR VPWR sky130_fd_sc_hd__decap_3
XFILLER_29_582 VGND VGND VPWR VPWR sky130_fd_sc_hd__decap_3
XFILLER_63_327 VGND VGND VPWR VPWR sky130_fd_sc_hd__decap_3
XFILLER_84_42 VGND VGND VPWR VPWR sky130_fd_sc_hd__decap_3
XFILLER_90_113 VGND VGND VPWR VPWR sky130_fd_sc_hd__decap_3
XFILLER_63_349 VGND VGND VPWR VPWR sky130_fd_sc_hd__fill_1
XFILLER_75_198 VGND VGND VPWR VPWR sky130_fd_sc_hd__decap_3
XFILLER_91_647 VGND VGND VPWR VPWR sky130_fd_sc_hd__decap_3
Xplace327 _4599_/S VGND VGND VPWR VPWR _4601_/S sky130_fd_sc_hd__buf_2
Xplace316 _4577_/B VGND VGND VPWR VPWR _4563_/B sky130_fd_sc_hd__buf_2
Xplace305 _4315_/Y VGND VGND VPWR VPWR _5086_/A sky130_fd_sc_hd__buf_2
XFILLER_16_265 VGND VGND VPWR VPWR sky130_fd_sc_hd__decap_3
XFILLER_44_563 VGND VGND VPWR VPWR sky130_fd_sc_hd__decap_3
Xplace349 _4093_/B VGND VGND VPWR VPWR _4394_/B sky130_fd_sc_hd__buf_2
Xplace338 _3591_/A VGND VGND VPWR VPWR _4376_/A sky130_fd_sc_hd__buf_2
XTAP_TAPCELL_ROW_14_422 VGND VPWR sky130_fd_sc_hd__tapvpwrvgnd_1
XTAP_TAPCELL_ROW_42_753 VGND VPWR sky130_fd_sc_hd__tapvpwrvgnd_1
XFILLER_76_6 VGND VGND VPWR VPWR sky130_fd_sc_hd__decap_3
XFILLER_8_442 VGND VGND VPWR VPWR sky130_fd_sc_hd__decap_3
X_4350_ _7065_/Q _4305_/B _4205_/A VGND VGND VPWR VPWR _4367_/B sky130_fd_sc_hd__o21a_2
XTAP_TAPCELL_ROW_113_1605 VGND VPWR sky130_fd_sc_hd__tapvpwrvgnd_1
X_3301_ _6981_/Q _6980_/Q VGND VGND VPWR VPWR _3519_/B sky130_fd_sc_hd__nand2_4
XFILLER_113_535 VGND VGND VPWR VPWR sky130_fd_sc_hd__decap_3
XFILLER_4_681 VGND VGND VPWR VPWR sky130_fd_sc_hd__decap_3
X_4281_ _7254_/Q _4599_/S _4278_/X _4280_/X VGND VGND VPWR VPWR _4281_/X sky130_fd_sc_hd__a211o_2
XFILLER_98_246 VGND VGND VPWR VPWR sky130_fd_sc_hd__decap_3
XFILLER_98_224 VGND VGND VPWR VPWR sky130_fd_sc_hd__decap_3
XFILLER_113_579 VGND VGND VPWR VPWR sky130_fd_sc_hd__decap_3
XFILLER_67_600 VGND VGND VPWR VPWR sky130_fd_sc_hd__decap_3
XFILLER_79_460 VGND VGND VPWR VPWR sky130_fd_sc_hd__fill_1
XFILLER_86_408 VGND VGND VPWR VPWR sky130_fd_sc_hd__decap_3
Xclkbuf_leaf_3_clk clkload0/A VGND VGND VPWR VPWR _6974_/CLK sky130_fd_sc_hd__clkbuf_16
XFILLER_98_268 VGND VGND VPWR VPWR sky130_fd_sc_hd__decap_3
XFILLER_39_324 VGND VGND VPWR VPWR sky130_fd_sc_hd__decap_3
XFILLER_67_644 VGND VGND VPWR VPWR sky130_fd_sc_hd__decap_3
XFILLER_54_305 VGND VGND VPWR VPWR sky130_fd_sc_hd__decap_3
XFILLER_54_327 VGND VGND VPWR VPWR sky130_fd_sc_hd__decap_3
XFILLER_67_688 VGND VGND VPWR VPWR sky130_fd_sc_hd__decap_3
XFILLER_81_113 VGND VGND VPWR VPWR sky130_fd_sc_hd__decap_3
XFILLER_82_625 VGND VGND VPWR VPWR sky130_fd_sc_hd__decap_3
XFILLER_81_146 VGND VGND VPWR VPWR sky130_fd_sc_hd__decap_3
XFILLER_82_669 VGND VGND VPWR VPWR sky130_fd_sc_hd__decap_3
X_6922_ _7378_/CLK _6922_/D VGND VGND VPWR VPWR _6922_/Q sky130_fd_sc_hd__dfxtp_2
X_6853_ _6978_/CLK _6853_/D VGND VGND VPWR VPWR _6853_/Q sky130_fd_sc_hd__dfxtp_2
XFILLER_35_585 VGND VGND VPWR VPWR sky130_fd_sc_hd__decap_3
XFILLER_50_533 VGND VGND VPWR VPWR sky130_fd_sc_hd__decap_3
Xfanout17 _6662_/A VGND VGND VPWR VPWR _6629_/A sky130_fd_sc_hd__buf_2
Xfanout28 fanout33/X VGND VGND VPWR VPWR _6625_/A sky130_fd_sc_hd__buf_2
XFILLER_22_235 VGND VGND VPWR VPWR sky130_fd_sc_hd__fill_2
XFILLER_50_566 VGND VGND VPWR VPWR sky130_fd_sc_hd__decap_3
Xfanout39 _6570_/A VGND VGND VPWR VPWR _6602_/A sky130_fd_sc_hd__buf_2
X_6784_ clkload8/A _6784_/D VGND VGND VPWR VPWR _6784_/Q sky130_fd_sc_hd__dfxtp_2
X_3996_ _7344_/Q _4534_/A0 _3996_/S VGND VGND VPWR VPWR _7344_/D sky130_fd_sc_hd__mux2_2
XFILLER_22_279 VGND VGND VPWR VPWR sky130_fd_sc_hd__decap_3
X_5735_ _7373_/Q hold957/X _5735_/S VGND VGND VPWR VPWR _6717_/D sky130_fd_sc_hd__mux2_2
X_5666_ _5666_/A _5666_/B VGND VGND VPWR VPWR _5668_/B sky130_fd_sc_hd__or2_2
XTAP_TAPCELL_ROW_79_1202 VGND VPWR sky130_fd_sc_hd__tapvpwrvgnd_1
X_7405_ _7405_/CLK _7405_/D _6685_/Y VGND VGND VPWR VPWR _7405_/Q sky130_fd_sc_hd__dfrtp_2
X_4617_ _5114_/B _4617_/B _4617_/C VGND VGND VPWR VPWR _5099_/A sky130_fd_sc_hd__or3_4
X_5597_ hold932/X _5587_/B _5154_/Y VGND VGND VPWR VPWR _7029_/D sky130_fd_sc_hd__a21o_2
XFILLER_104_513 VGND VGND VPWR VPWR sky130_fd_sc_hd__decap_3
XFILLER_2_607 VGND VGND VPWR VPWR sky130_fd_sc_hd__decap_3
XFILLER_89_213 VGND VGND VPWR VPWR sky130_fd_sc_hd__decap_3
X_7336_ _7368_/CLK _7336_/D _6616_/Y VGND VGND VPWR VPWR _7336_/Q sky130_fd_sc_hd__dfrtp_2
X_4548_ _4548_/A _4563_/B VGND VGND VPWR VPWR _7306_/D sky130_fd_sc_hd__and2_2
XFILLER_104_557 VGND VGND VPWR VPWR sky130_fd_sc_hd__decap_3
X_7267_ _7395_/CLK _7267_/D _6547_/Y VGND VGND VPWR VPWR _7267_/Q sky130_fd_sc_hd__dfrtp_2
XFILLER_58_622 VGND VGND VPWR VPWR sky130_fd_sc_hd__decap_3
X_7198_ _7362_/CLK _7198_/D _6478_/Y VGND VGND VPWR VPWR _7198_/Q sky130_fd_sc_hd__dfrtp_2
XFILLER_57_121 VGND VGND VPWR VPWR sky130_fd_sc_hd__decap_3
XFILLER_58_666 VGND VGND VPWR VPWR sky130_fd_sc_hd__decap_3
XFILLER_73_603 VGND VGND VPWR VPWR sky130_fd_sc_hd__decap_3
XFILLER_85_441 VGND VGND VPWR VPWR sky130_fd_sc_hd__decap_3
Xhold1120 _7237_/Q VGND VGND VPWR VPWR _5182_/A sky130_fd_sc_hd__dlygate4sd3_1
Xhold1131 _7152_/Q VGND VGND VPWR VPWR _5358_/A0 sky130_fd_sc_hd__dlygate4sd3_1
Xhold1142 _4480_/X VGND VGND VPWR VPWR _7339_/D sky130_fd_sc_hd__dlygate4sd3_1
XFILLER_57_165 VGND VGND VPWR VPWR sky130_fd_sc_hd__decap_3
XFILLER_57_187 VGND VGND VPWR VPWR sky130_fd_sc_hd__fill_2
XFILLER_85_485 VGND VGND VPWR VPWR sky130_fd_sc_hd__decap_3
Xhold1153 _7135_/Q VGND VGND VPWR VPWR _5396_/A0 sky130_fd_sc_hd__dlygate4sd3_1
Xhold1164 _7148_/Q VGND VGND VPWR VPWR _5369_/A0 sky130_fd_sc_hd__dlygate4sd3_1
Xhold1175 _7147_/Q VGND VGND VPWR VPWR _5371_/A0 sky130_fd_sc_hd__dlygate4sd3_1
XPHY_EDGE_ROW_79_Right_79 VGND VGND VPWR VPWR sky130_fd_sc_hd__decap_3
XFILLER_73_647 VGND VGND VPWR VPWR sky130_fd_sc_hd__decap_3
Xhold1186 _7307_/Q VGND VGND VPWR VPWR _4546_/A sky130_fd_sc_hd__dlygate4sd3_1
Xhold1197 _7145_/Q VGND VGND VPWR VPWR _5375_/A0 sky130_fd_sc_hd__dlygate4sd3_1
XFILLER_26_574 VGND VGND VPWR VPWR sky130_fd_sc_hd__decap_3
XFILLER_54_45 VGND VGND VPWR VPWR sky130_fd_sc_hd__decap_3
XFILLER_41_522 VGND VGND VPWR VPWR sky130_fd_sc_hd__fill_2
XFILLER_53_393 VGND VGND VPWR VPWR sky130_fd_sc_hd__fill_1
XFILLER_110_62 VGND VGND VPWR VPWR sky130_fd_sc_hd__decap_3
XFILLER_13_246 VGND VGND VPWR VPWR sky130_fd_sc_hd__decap_3
XFILLER_41_588 VGND VGND VPWR VPWR sky130_fd_sc_hd__decap_3
XFILLER_9_228 VGND VGND VPWR VPWR sky130_fd_sc_hd__decap_3
XFILLER_70_99 VGND VGND VPWR VPWR sky130_fd_sc_hd__decap_3
XPHY_EDGE_ROW_88_Right_88 VGND VGND VPWR VPWR sky130_fd_sc_hd__decap_3
XFILLER_107_340 VGND VGND VPWR VPWR sky130_fd_sc_hd__decap_3
XFILLER_79_86 VGND VGND VPWR VPWR sky130_fd_sc_hd__decap_3
XFILLER_110_516 VGND VGND VPWR VPWR sky130_fd_sc_hd__decap_3
XFILLER_1_662 VGND VGND VPWR VPWR sky130_fd_sc_hd__decap_3
XFILLER_49_600 VGND VGND VPWR VPWR sky130_fd_sc_hd__decap_3
XFILLER_1_673 VGND VGND VPWR VPWR sky130_fd_sc_hd__decap_3
XFILLER_0_194 VGND VGND VPWR VPWR sky130_fd_sc_hd__fill_2
XFILLER_49_644 VGND VGND VPWR VPWR sky130_fd_sc_hd__decap_3
XFILLER_76_441 VGND VGND VPWR VPWR sky130_fd_sc_hd__decap_3
XFILLER_95_74 VGND VGND VPWR VPWR sky130_fd_sc_hd__fill_1
XPHY_EDGE_ROW_97_Right_97 VGND VGND VPWR VPWR sky130_fd_sc_hd__decap_3
XFILLER_36_305 VGND VGND VPWR VPWR sky130_fd_sc_hd__decap_3
XFILLER_36_327 VGND VGND VPWR VPWR sky130_fd_sc_hd__decap_3
XFILLER_49_688 VGND VGND VPWR VPWR sky130_fd_sc_hd__decap_3
XFILLER_64_625 VGND VGND VPWR VPWR sky130_fd_sc_hd__decap_3
XFILLER_95_96 VGND VGND VPWR VPWR sky130_fd_sc_hd__decap_3
XTAP_TAPCELL_ROW_47_812 VGND VPWR sky130_fd_sc_hd__tapvpwrvgnd_1
XFILLER_63_113 VGND VGND VPWR VPWR sky130_fd_sc_hd__fill_2
XFILLER_64_669 VGND VGND VPWR VPWR sky130_fd_sc_hd__decap_3
XFILLER_17_541 VGND VGND VPWR VPWR sky130_fd_sc_hd__decap_3
XFILLER_51_319 VGND VGND VPWR VPWR sky130_fd_sc_hd__decap_3
XFILLER_91_477 VGND VGND VPWR VPWR sky130_fd_sc_hd__decap_3
XFILLER_17_585 VGND VGND VPWR VPWR sky130_fd_sc_hd__decap_3
XTAP_TAPCELL_ROW_63_1003 VGND VPWR sky130_fd_sc_hd__tapvpwrvgnd_1
XTAP_TAPCELL_ROW_27_580 VGND VPWR sky130_fd_sc_hd__tapvpwrvgnd_1
X_3850_ _6810_/Q _3890_/B1 _3852_/B1 _6820_/Q VGND VGND VPWR VPWR _3850_/X sky130_fd_sc_hd__a22o_2
XPHY_EDGE_ROW_4_Left_121 VGND VGND VPWR VPWR sky130_fd_sc_hd__decap_3
X_3781_ _6949_/Q _3890_/B1 _3852_/B1 _6961_/Q _3780_/X VGND VGND VPWR VPWR _3781_/X
+ sky130_fd_sc_hd__a221o_2
XFILLER_74_3 VGND VGND VPWR VPWR sky130_fd_sc_hd__decap_3
XFILLER_8_261 VGND VGND VPWR VPWR sky130_fd_sc_hd__decap_3
XFILLER_8_283 VGND VGND VPWR VPWR sky130_fd_sc_hd__decap_3
Xoutput536 _7003_/Q VGND VGND VPWR VPWR pc_out[26] sky130_fd_sc_hd__clkdlybuf4s25_1
Xoutput525 _6993_/Q VGND VGND VPWR VPWR pc_out[16] sky130_fd_sc_hd__clkdlybuf4s25_1
Xoutput514 _3339_/C1 VGND VGND VPWR VPWR instruction_out[6] sky130_fd_sc_hd__clkdlybuf4s25_1
Xoutput503 _3449_/C VGND VGND VPWR VPWR instruction_out[23] sky130_fd_sc_hd__clkdlybuf4s25_1
X_4402_ _7082_/Q _4102_/B _4432_/B1 _4401_/X VGND VGND VPWR VPWR _4403_/A sky130_fd_sc_hd__o211a_2
XFILLER_99_511 VGND VGND VPWR VPWR sky130_fd_sc_hd__decap_3
X_7121_ _7351_/CLK _7121_/D _6401_/Y VGND VGND VPWR VPWR _7121_/Q sky130_fd_sc_hd__dfrtp_2
Xoutput547 _6984_/Q VGND VGND VPWR VPWR pc_out[7] sky130_fd_sc_hd__clkdlybuf4s25_1
X_4333_ _7127_/Q _4351_/B1 _4332_/X VGND VGND VPWR VPWR _4336_/A sky130_fd_sc_hd__a21o_2
XTAP_TAPCELL_ROW_74_1143 VGND VPWR sky130_fd_sc_hd__tapvpwrvgnd_1
XFILLER_99_544 VGND VGND VPWR VPWR sky130_fd_sc_hd__decap_3
XFILLER_101_505 VGND VGND VPWR VPWR sky130_fd_sc_hd__decap_3
XFILLER_113_343 VGND VGND VPWR VPWR sky130_fd_sc_hd__decap_3
XFILLER_115_18 VGND VGND VPWR VPWR sky130_fd_sc_hd__decap_3
X_7052_ _7406_/CLK _7052_/D _6332_/Y VGND VGND VPWR VPWR _7052_/Q sky130_fd_sc_hd__dfrtp_2
X_4264_ _4264_/A _4264_/B VGND VGND VPWR VPWR _4376_/B sky130_fd_sc_hd__nor2_2
XFILLER_99_588 VGND VGND VPWR VPWR sky130_fd_sc_hd__decap_3
XFILLER_101_538 VGND VGND VPWR VPWR sky130_fd_sc_hd__decap_3
XFILLER_113_387 VGND VGND VPWR VPWR sky130_fd_sc_hd__decap_3
XFILLER_79_290 VGND VGND VPWR VPWR sky130_fd_sc_hd__decap_3
X_4195_ _7135_/Q _4267_/A2 _4267_/B1 _7167_/Q VGND VGND VPWR VPWR _4195_/X sky130_fd_sc_hd__a22o_2
XFILLER_27_305 VGND VGND VPWR VPWR sky130_fd_sc_hd__decap_3
XFILLER_54_102 VGND VGND VPWR VPWR sky130_fd_sc_hd__decap_3
XFILLER_55_603 VGND VGND VPWR VPWR sky130_fd_sc_hd__decap_3
XFILLER_94_271 VGND VGND VPWR VPWR sky130_fd_sc_hd__fill_2
XFILLER_39_187 VGND VGND VPWR VPWR sky130_fd_sc_hd__fill_1
XFILLER_55_647 VGND VGND VPWR VPWR sky130_fd_sc_hd__decap_3
XFILLER_82_433 VGND VGND VPWR VPWR sky130_fd_sc_hd__decap_3
XFILLER_70_628 VGND VGND VPWR VPWR sky130_fd_sc_hd__decap_3
X_6905_ _6966_/CLK _6905_/D VGND VGND VPWR VPWR _6905_/Q sky130_fd_sc_hd__dfxtp_2
XTAP_TAPCELL_ROW_85_1272 VGND VPWR sky130_fd_sc_hd__tapvpwrvgnd_1
XFILLER_23_555 VGND VGND VPWR VPWR sky130_fd_sc_hd__decap_3
XFILLER_35_393 VGND VGND VPWR VPWR sky130_fd_sc_hd__fill_1
X_6836_ clkload6/A _6836_/D VGND VGND VPWR VPWR _6836_/Q sky130_fd_sc_hd__dfxtp_2
XPHY_EDGE_ROW_59_Left_176 VGND VGND VPWR VPWR sky130_fd_sc_hd__decap_3
XFILLER_23_588 VGND VGND VPWR VPWR sky130_fd_sc_hd__decap_3
X_6767_ _6970_/CLK _6767_/D VGND VGND VPWR VPWR _6767_/Q sky130_fd_sc_hd__dfxtp_2
XFILLER_10_227 VGND VGND VPWR VPWR sky130_fd_sc_hd__decap_3
X_3979_ _7351_/Q _4520_/A0 _3989_/S VGND VGND VPWR VPWR _7351_/D sky130_fd_sc_hd__mux2_2
XFILLER_109_638 VGND VGND VPWR VPWR sky130_fd_sc_hd__decap_3
X_6698_ _6965_/CLK _6698_/D VGND VGND VPWR VPWR _6698_/Q sky130_fd_sc_hd__dfxtp_2
X_5649_ _5649_/A VGND VGND VPWR VPWR _5649_/X sky130_fd_sc_hd__buf_1
XFILLER_104_321 VGND VGND VPWR VPWR sky130_fd_sc_hd__decap_3
XFILLER_116_181 VGND VGND VPWR VPWR sky130_fd_sc_hd__fill_2
XFILLER_2_448 VGND VGND VPWR VPWR sky130_fd_sc_hd__fill_1
XFILLER_6_6 VGND VGND VPWR VPWR sky130_fd_sc_hd__decap_3
X_7319_ _7351_/CLK _7319_/D _6599_/Y VGND VGND VPWR VPWR _7319_/Q sky130_fd_sc_hd__dfrtp_2
XPHY_EDGE_ROW_68_Left_185 VGND VGND VPWR VPWR sky130_fd_sc_hd__decap_3
XFILLER_104_354 VGND VGND VPWR VPWR sky130_fd_sc_hd__fill_2
XFILLER_104_365 VGND VGND VPWR VPWR sky130_fd_sc_hd__decap_3
XFILLER_77_216 VGND VGND VPWR VPWR sky130_fd_sc_hd__decap_3
XFILLER_105_51 VGND VGND VPWR VPWR sky130_fd_sc_hd__decap_3
XFILLER_58_430 VGND VGND VPWR VPWR sky130_fd_sc_hd__fill_1
XFILLER_58_441 VGND VGND VPWR VPWR sky130_fd_sc_hd__decap_3
XFILLER_100_560 VGND VGND VPWR VPWR sky130_fd_sc_hd__decap_3
XFILLER_46_625 VGND VGND VPWR VPWR sky130_fd_sc_hd__decap_3
XFILLER_73_411 VGND VGND VPWR VPWR sky130_fd_sc_hd__fill_2
XFILLER_33_308 VGND VGND VPWR VPWR sky130_fd_sc_hd__decap_3
XFILLER_46_669 VGND VGND VPWR VPWR sky130_fd_sc_hd__decap_3
XFILLER_61_606 VGND VGND VPWR VPWR sky130_fd_sc_hd__decap_3
XFILLER_61_617 VGND VGND VPWR VPWR sky130_fd_sc_hd__decap_3
XFILLER_33_319 VGND VGND VPWR VPWR sky130_fd_sc_hd__decap_3
XPHY_EDGE_ROW_77_Left_194 VGND VGND VPWR VPWR sky130_fd_sc_hd__decap_3
XFILLER_14_533 VGND VGND VPWR VPWR sky130_fd_sc_hd__decap_3
XFILLER_14_566 VGND VGND VPWR VPWR sky130_fd_sc_hd__decap_3
XFILLER_60_138 VGND VGND VPWR VPWR sky130_fd_sc_hd__fill_2
XTAP_TAPCELL_ROW_52_881 VGND VPWR sky130_fd_sc_hd__tapvpwrvgnd_1
XTAP_TAPCELL_ROW_52_870 VGND VPWR sky130_fd_sc_hd__tapvpwrvgnd_1
XFILLER_5_231 VGND VGND VPWR VPWR sky130_fd_sc_hd__decap_3
XFILLER_108_660 VGND VGND VPWR VPWR sky130_fd_sc_hd__decap_3
XFILLER_5_242 VGND VGND VPWR VPWR sky130_fd_sc_hd__decap_3
XFILLER_114_118 VGND VGND VPWR VPWR sky130_fd_sc_hd__fill_2
XFILLER_114_129 VGND VGND VPWR VPWR sky130_fd_sc_hd__decap_3
XFILLER_107_192 VGND VGND VPWR VPWR sky130_fd_sc_hd__decap_3
XFILLER_96_503 VGND VGND VPWR VPWR sky130_fd_sc_hd__decap_3
XFILLER_39_6 VGND VGND VPWR VPWR sky130_fd_sc_hd__fill_2
XFILLER_96_536 VGND VGND VPWR VPWR sky130_fd_sc_hd__decap_3
XFILLER_1_481 VGND VGND VPWR VPWR sky130_fd_sc_hd__decap_3
XFILLER_96_569 VGND VGND VPWR VPWR sky130_fd_sc_hd__decap_3
XFILLER_110_368 VGND VGND VPWR VPWR sky130_fd_sc_hd__decap_3
XFILLER_37_603 VGND VGND VPWR VPWR sky130_fd_sc_hd__decap_3
XFILLER_49_452 VGND VGND VPWR VPWR sky130_fd_sc_hd__decap_3
XFILLER_37_647 VGND VGND VPWR VPWR sky130_fd_sc_hd__decap_3
XTAP_TAPCELL_ROW_108_1548 VGND VPWR sky130_fd_sc_hd__tapvpwrvgnd_1
XFILLER_64_477 VGND VGND VPWR VPWR sky130_fd_sc_hd__decap_3
XFILLER_52_628 VGND VGND VPWR VPWR sky130_fd_sc_hd__decap_3
X_4951_ _4949_/Y _4950_/Y _4918_/B VGND VGND VPWR VPWR _4951_/Y sky130_fd_sc_hd__a21oi_2
XFILLER_17_393 VGND VGND VPWR VPWR sky130_fd_sc_hd__decap_3
XFILLER_32_330 VGND VGND VPWR VPWR sky130_fd_sc_hd__decap_3
X_4882_ _4882_/A _4882_/B VGND VGND VPWR VPWR _6998_/D sky130_fd_sc_hd__and2_2
X_3902_ _6918_/Q _3926_/A2 _3902_/B1 _6870_/Q VGND VGND VPWR VPWR _3902_/X sky130_fd_sc_hd__a22o_2
XFILLER_60_672 VGND VGND VPWR VPWR sky130_fd_sc_hd__decap_3
X_6621_ _6622_/A VGND VGND VPWR VPWR _6621_/Y sky130_fd_sc_hd__inv_2
X_3833_ _7388_/Q _3832_/X _3833_/S VGND VGND VPWR VPWR _7388_/D sky130_fd_sc_hd__mux2_2
XFILLER_20_525 VGND VGND VPWR VPWR sky130_fd_sc_hd__decap_3
XFILLER_20_536 VGND VGND VPWR VPWR sky130_fd_sc_hd__decap_3
XFILLER_20_569 VGND VGND VPWR VPWR sky130_fd_sc_hd__decap_3
X_6552_ _6654_/A VGND VGND VPWR VPWR _6552_/Y sky130_fd_sc_hd__inv_2
X_3764_ _6706_/Q _6796_/Q _6884_/Q _6932_/Q _3991_/B _3665_/B VGND VGND VPWR VPWR
+ _3764_/X sky130_fd_sc_hd__mux4_2
XFILLER_9_570 VGND VGND VPWR VPWR sky130_fd_sc_hd__decap_3
X_6483_ _6652_/A VGND VGND VPWR VPWR _6483_/Y sky130_fd_sc_hd__inv_2
X_3695_ _6714_/Q _3917_/A2 _3902_/B1 _6892_/Q VGND VGND VPWR VPWR _3695_/X sky130_fd_sc_hd__a22o_2
XFILLER_105_107 VGND VGND VPWR VPWR sky130_fd_sc_hd__decap_3
XFILLER_106_619 VGND VGND VPWR VPWR sky130_fd_sc_hd__decap_3
XFILLER_114_663 VGND VGND VPWR VPWR sky130_fd_sc_hd__decap_3
X_7104_ _7328_/CLK _7104_/D _6384_/Y VGND VGND VPWR VPWR _7104_/Q sky130_fd_sc_hd__dfrtp_2
X_5365_ _5365_/A0 _4716_/X _5383_/S VGND VGND VPWR VPWR _7150_/D sky130_fd_sc_hd__mux2_4
XFILLER_99_352 VGND VGND VPWR VPWR sky130_fd_sc_hd__decap_3
XFILLER_101_313 VGND VGND VPWR VPWR sky130_fd_sc_hd__decap_3
XFILLER_59_216 VGND VGND VPWR VPWR sky130_fd_sc_hd__decap_3
XFILLER_87_525 VGND VGND VPWR VPWR sky130_fd_sc_hd__decap_3
X_5296_ _5296_/A0 _4716_/X _5315_/S VGND VGND VPWR VPWR _7182_/D sky130_fd_sc_hd__mux2_4
X_4316_ _7226_/Q _4349_/B1 _4348_/B1 _7130_/Q VGND VGND VPWR VPWR _4316_/X sky130_fd_sc_hd__a22o_2
XFILLER_101_346 VGND VGND VPWR VPWR sky130_fd_sc_hd__decap_3
XFILLER_87_558 VGND VGND VPWR VPWR sky130_fd_sc_hd__fill_2
X_7035_ _7383_/CLK _7035_/D _6315_/Y VGND VGND VPWR VPWR _7035_/Q sky130_fd_sc_hd__dfrtp_2
X_4247_ _7261_/Q _4356_/A2 _3968_/S _7325_/Q _4246_/X VGND VGND VPWR VPWR _4248_/C
+ sky130_fd_sc_hd__a221o_2
XFILLER_28_625 VGND VGND VPWR VPWR sky130_fd_sc_hd__decap_3
X_4178_ _7264_/Q _4356_/A2 _4177_/X VGND VGND VPWR VPWR _4178_/Y sky130_fd_sc_hd__a21oi_2
XTAP_TAPCELL_ROW_87_1301 VGND VPWR sky130_fd_sc_hd__tapvpwrvgnd_1
XFILLER_27_113 VGND VGND VPWR VPWR sky130_fd_sc_hd__fill_1
XFILLER_55_411 VGND VGND VPWR VPWR sky130_fd_sc_hd__fill_1
XFILLER_55_433 VGND VGND VPWR VPWR sky130_fd_sc_hd__fill_1
XFILLER_67_293 VGND VGND VPWR VPWR sky130_fd_sc_hd__decap_3
XFILLER_95_591 VGND VGND VPWR VPWR sky130_fd_sc_hd__decap_3
XFILLER_27_146 VGND VGND VPWR VPWR sky130_fd_sc_hd__decap_3
XFILLER_28_669 VGND VGND VPWR VPWR sky130_fd_sc_hd__decap_3
XFILLER_35_14 VGND VGND VPWR VPWR sky130_fd_sc_hd__fill_1
XFILLER_43_606 VGND VGND VPWR VPWR sky130_fd_sc_hd__decap_3
XFILLER_43_617 VGND VGND VPWR VPWR sky130_fd_sc_hd__decap_3
XFILLER_55_455 VGND VGND VPWR VPWR sky130_fd_sc_hd__decap_3
XTAP_TAPCELL_ROW_2_278 VGND VPWR sky130_fd_sc_hd__tapvpwrvgnd_1
XFILLER_51_650 VGND VGND VPWR VPWR sky130_fd_sc_hd__decap_3
XFILLER_70_447 VGND VGND VPWR VPWR sky130_fd_sc_hd__decap_3
XFILLER_23_374 VGND VGND VPWR VPWR sky130_fd_sc_hd__decap_3
X_6819_ _6974_/CLK _6819_/D VGND VGND VPWR VPWR _6819_/Q sky130_fd_sc_hd__dfxtp_2
XFILLER_11_547 VGND VGND VPWR VPWR sky130_fd_sc_hd__decap_3
XFILLER_23_396 VGND VGND VPWR VPWR sky130_fd_sc_hd__fill_2
XFILLER_51_57 VGND VGND VPWR VPWR sky130_fd_sc_hd__decap_3
XFILLER_7_529 VGND VGND VPWR VPWR sky130_fd_sc_hd__decap_3
XTAP_TAPCELL_ROW_98_1430 VGND VPWR sky130_fd_sc_hd__tapvpwrvgnd_1
XFILLER_109_435 VGND VGND VPWR VPWR sky130_fd_sc_hd__decap_3
XFILLER_109_479 VGND VGND VPWR VPWR sky130_fd_sc_hd__decap_3
XFILLER_2_223 VGND VGND VPWR VPWR sky130_fd_sc_hd__fill_1
XFILLER_105_641 VGND VGND VPWR VPWR sky130_fd_sc_hd__decap_3
XFILLER_2_245 VGND VGND VPWR VPWR sky130_fd_sc_hd__decap_3
XFILLER_105_685 VGND VGND VPWR VPWR sky130_fd_sc_hd__decap_3
XFILLER_2_278 VGND VGND VPWR VPWR sky130_fd_sc_hd__decap_3
XFILLER_78_536 VGND VGND VPWR VPWR sky130_fd_sc_hd__decap_3
XFILLER_116_72 VGND VGND VPWR VPWR sky130_fd_sc_hd__fill_1
XFILLER_116_94 VGND VGND VPWR VPWR sky130_fd_sc_hd__fill_1
XFILLER_76_32 VGND VGND VPWR VPWR sky130_fd_sc_hd__fill_1
XFILLER_78_569 VGND VGND VPWR VPWR sky130_fd_sc_hd__decap_3
XFILLER_19_603 VGND VGND VPWR VPWR sky130_fd_sc_hd__decap_3
XFILLER_58_260 VGND VGND VPWR VPWR sky130_fd_sc_hd__decap_3
XFILLER_65_208 VGND VGND VPWR VPWR sky130_fd_sc_hd__fill_1
XFILLER_76_76 VGND VGND VPWR VPWR sky130_fd_sc_hd__decap_3
XFILLER_93_517 VGND VGND VPWR VPWR sky130_fd_sc_hd__decap_3
XFILLER_18_113 VGND VGND VPWR VPWR sky130_fd_sc_hd__fill_2
XFILLER_19_647 VGND VGND VPWR VPWR sky130_fd_sc_hd__decap_3
XFILLER_76_98 VGND VGND VPWR VPWR sky130_fd_sc_hd__decap_3
XFILLER_46_444 VGND VGND VPWR VPWR sky130_fd_sc_hd__fill_1
XFILLER_46_477 VGND VGND VPWR VPWR sky130_fd_sc_hd__fill_1
XFILLER_73_252 VGND VGND VPWR VPWR sky130_fd_sc_hd__decap_3
XFILLER_92_20 VGND VGND VPWR VPWR sky130_fd_sc_hd__decap_3
XTAP_TAPCELL_ROW_57_940 VGND VPWR sky130_fd_sc_hd__tapvpwrvgnd_1
XPHY_EDGE_ROW_85_Left_202 VGND VGND VPWR VPWR sky130_fd_sc_hd__decap_3
XFILLER_18_179 VGND VGND VPWR VPWR sky130_fd_sc_hd__decap_3
XFILLER_34_628 VGND VGND VPWR VPWR sky130_fd_sc_hd__decap_3
XFILLER_73_274 VGND VGND VPWR VPWR sky130_fd_sc_hd__decap_3
XFILLER_73_296 VGND VGND VPWR VPWR sky130_fd_sc_hd__decap_3
XFILLER_61_458 VGND VGND VPWR VPWR sky130_fd_sc_hd__decap_3
XFILLER_42_672 VGND VGND VPWR VPWR sky130_fd_sc_hd__decap_3
XFILLER_41_182 VGND VGND VPWR VPWR sky130_fd_sc_hd__fill_1
XTAP_TAPCELL_ROW_103_1489 VGND VPWR sky130_fd_sc_hd__tapvpwrvgnd_1
XPHY_EDGE_ROW_94_Left_211 VGND VGND VPWR VPWR sky130_fd_sc_hd__decap_3
XFILLER_115_405 VGND VGND VPWR VPWR sky130_fd_sc_hd__decap_3
XFILLER_6_551 VGND VGND VPWR VPWR sky130_fd_sc_hd__decap_3
X_3480_ _7088_/Q _3417_/X _3407_/X _7120_/Q VGND VGND VPWR VPWR _3482_/B sky130_fd_sc_hd__a22o_2
XFILLER_115_438 VGND VGND VPWR VPWR sky130_fd_sc_hd__decap_3
XFILLER_115_449 VGND VGND VPWR VPWR sky130_fd_sc_hd__decap_3
XFILLER_6_584 VGND VGND VPWR VPWR sky130_fd_sc_hd__decap_3
XFILLER_6_595 VGND VGND VPWR VPWR sky130_fd_sc_hd__decap_3
XTAP_TAPCELL_ROW_71_1102 VGND VPWR sky130_fd_sc_hd__tapvpwrvgnd_1
XFILLER_111_600 VGND VGND VPWR VPWR sky130_fd_sc_hd__decap_3
XFILLER_37_3 VGND VGND VPWR VPWR sky130_fd_sc_hd__fill_2
XFILLER_69_514 VGND VGND VPWR VPWR sky130_fd_sc_hd__decap_3
XFILLER_96_300 VGND VGND VPWR VPWR sky130_fd_sc_hd__fill_2
X_5150_ _3501_/X _3618_/X _5145_/X _5149_/Y VGND VGND VPWR VPWR _5659_/B sky130_fd_sc_hd__a31o_2
XFILLER_111_644 VGND VGND VPWR VPWR sky130_fd_sc_hd__decap_3
XFILLER_69_547 VGND VGND VPWR VPWR sky130_fd_sc_hd__decap_3
XFILLER_96_322 VGND VGND VPWR VPWR sky130_fd_sc_hd__decap_3
X_4101_ _7141_/Q _4428_/B1 _4100_/X VGND VGND VPWR VPWR _4141_/A sky130_fd_sc_hd__a21oi_2
XFILLER_111_688 VGND VGND VPWR VPWR sky130_fd_sc_hd__decap_3
X_4032_ _7246_/Q _4433_/B _3947_/S _7214_/Q VGND VGND VPWR VPWR _4032_/X sky130_fd_sc_hd__a22o_2
XFILLER_37_422 VGND VGND VPWR VPWR sky130_fd_sc_hd__decap_3
XFILLER_77_591 VGND VGND VPWR VPWR sky130_fd_sc_hd__decap_3
XFILLER_84_539 VGND VGND VPWR VPWR sky130_fd_sc_hd__decap_3
XFILLER_25_606 VGND VGND VPWR VPWR sky130_fd_sc_hd__decap_3
XFILLER_37_466 VGND VGND VPWR VPWR sky130_fd_sc_hd__decap_3
XFILLER_24_116 VGND VGND VPWR VPWR sky130_fd_sc_hd__decap_3
XFILLER_25_617 VGND VGND VPWR VPWR sky130_fd_sc_hd__decap_3
XFILLER_64_274 VGND VGND VPWR VPWR sky130_fd_sc_hd__decap_3
XFILLER_92_572 VGND VGND VPWR VPWR sky130_fd_sc_hd__decap_3
XTAP_TAPCELL_ROW_69_1075 VGND VPWR sky130_fd_sc_hd__tapvpwrvgnd_1
XFILLER_52_436 VGND VGND VPWR VPWR sky130_fd_sc_hd__decap_3
XTAP_TAPCELL_ROW_82_1231 VGND VPWR sky130_fd_sc_hd__tapvpwrvgnd_1
XFILLER_33_650 VGND VGND VPWR VPWR sky130_fd_sc_hd__decap_3
XTAP_TAPCELL_ROW_35_667 VGND VPWR sky130_fd_sc_hd__tapvpwrvgnd_1
XANTENNA_12 _5633_/B VGND VGND VPWR VPWR sky130_fd_sc_hd__diode_2
XFILLER_20_322 VGND VGND VPWR VPWR sky130_fd_sc_hd__decap_3
XFILLER_32_193 VGND VGND VPWR VPWR sky130_fd_sc_hd__decap_3
XFILLER_60_480 VGND VGND VPWR VPWR sky130_fd_sc_hd__decap_3
X_4865_ _4865_/A0 _4864_/X _4946_/S VGND VGND VPWR VPWR _7270_/D sky130_fd_sc_hd__mux2_2
X_6604_ _6638_/A VGND VGND VPWR VPWR _6604_/Y sky130_fd_sc_hd__inv_2
X_4796_ _4795_/A _4779_/X _4447_/B _4780_/Y _4814_/A VGND VGND VPWR VPWR _4796_/Y
+ sky130_fd_sc_hd__a311oi_2
X_3816_ _6792_/Q _3926_/B1 _3925_/B1 _6880_/Q _3815_/X VGND VGND VPWR VPWR _3816_/X
+ sky130_fd_sc_hd__a221o_2
XFILLER_20_399 VGND VGND VPWR VPWR sky130_fd_sc_hd__fill_2
X_6535_ _6624_/A VGND VGND VPWR VPWR _6535_/Y sky130_fd_sc_hd__inv_2
X_3747_ _3741_/X _3743_/X _3745_/X _3746_/X VGND VGND VPWR VPWR _3747_/X sky130_fd_sc_hd__a22o_2
XFILLER_108_9 VGND VGND VPWR VPWR sky130_fd_sc_hd__decap_3
X_6466_ _6602_/A VGND VGND VPWR VPWR _6466_/Y sky130_fd_sc_hd__inv_2
X_6397_ _6462_/A VGND VGND VPWR VPWR _6397_/Y sky130_fd_sc_hd__inv_2
X_5417_ _5417_/A0 _5125_/Y _5429_/S VGND VGND VPWR VPWR _7125_/D sky130_fd_sc_hd__mux2_2
XFILLER_102_622 VGND VGND VPWR VPWR sky130_fd_sc_hd__decap_3
XFILLER_114_460 VGND VGND VPWR VPWR sky130_fd_sc_hd__decap_3
X_5348_ _5348_/A0 _5125_/Y _7412_/A VGND VGND VPWR VPWR _7157_/D sky130_fd_sc_hd__mux2_2
XTAP_TAPCELL_ROW_93_1371 VGND VPWR sky130_fd_sc_hd__tapvpwrvgnd_1
XTAP_TAPCELL_ROW_7_337 VGND VPWR sky130_fd_sc_hd__tapvpwrvgnd_1
XFILLER_101_143 VGND VGND VPWR VPWR sky130_fd_sc_hd__decap_3
XFILLER_102_666 VGND VGND VPWR VPWR sky130_fd_sc_hd__decap_3
XFILLER_47_219 VGND VGND VPWR VPWR sky130_fd_sc_hd__decap_3
XFILLER_87_366 VGND VGND VPWR VPWR sky130_fd_sc_hd__decap_3
XFILLER_87_388 VGND VGND VPWR VPWR sky130_fd_sc_hd__decap_3
X_7018_ _7332_/CLK _7018_/D _6298_/Y VGND VGND VPWR VPWR _7018_/Q sky130_fd_sc_hd__dfrtp_2
XFILLER_68_580 VGND VGND VPWR VPWR sky130_fd_sc_hd__decap_3
XFILLER_55_241 VGND VGND VPWR VPWR sky130_fd_sc_hd__fill_1
XFILLER_55_252 VGND VGND VPWR VPWR sky130_fd_sc_hd__decap_3
XFILLER_83_550 VGND VGND VPWR VPWR sky130_fd_sc_hd__decap_3
XFILLER_83_561 VGND VGND VPWR VPWR sky130_fd_sc_hd__decap_3
XFILLER_16_628 VGND VGND VPWR VPWR sky130_fd_sc_hd__decap_3
XFILLER_28_477 VGND VGND VPWR VPWR sky130_fd_sc_hd__fill_2
XFILLER_83_594 VGND VGND VPWR VPWR sky130_fd_sc_hd__decap_3
XFILLER_31_609 VGND VGND VPWR VPWR sky130_fd_sc_hd__decap_3
XFILLER_55_296 VGND VGND VPWR VPWR sky130_fd_sc_hd__fill_2
XFILLER_62_12 VGND VGND VPWR VPWR sky130_fd_sc_hd__decap_3
XFILLER_102_85 VGND VGND VPWR VPWR sky130_fd_sc_hd__fill_2
XFILLER_24_672 VGND VGND VPWR VPWR sky130_fd_sc_hd__decap_3
XFILLER_11_311 VGND VGND VPWR VPWR sky130_fd_sc_hd__decap_3
XFILLER_62_67 VGND VGND VPWR VPWR sky130_fd_sc_hd__fill_1
XFILLER_70_299 VGND VGND VPWR VPWR sky130_fd_sc_hd__decap_3
XFILLER_7_315 VGND VGND VPWR VPWR sky130_fd_sc_hd__decap_3
XFILLER_109_210 VGND VGND VPWR VPWR sky130_fd_sc_hd__decap_3
XFILLER_11_377 VGND VGND VPWR VPWR sky130_fd_sc_hd__decap_3
XFILLER_11_399 VGND VGND VPWR VPWR sky130_fd_sc_hd__decap_3
XFILLER_7_337 VGND VGND VPWR VPWR sky130_fd_sc_hd__decap_3
XFILLER_109_298 VGND VGND VPWR VPWR sky130_fd_sc_hd__decap_3
XFILLER_3_532 VGND VGND VPWR VPWR sky130_fd_sc_hd__decap_3
XFILLER_105_471 VGND VGND VPWR VPWR sky130_fd_sc_hd__decap_3
XFILLER_3_576 VGND VGND VPWR VPWR sky130_fd_sc_hd__decap_3
XFILLER_78_300 VGND VGND VPWR VPWR sky130_fd_sc_hd__decap_3
XFILLER_78_333 VGND VGND VPWR VPWR sky130_fd_sc_hd__decap_3
XFILLER_66_517 VGND VGND VPWR VPWR sky130_fd_sc_hd__decap_3
XFILLER_19_422 VGND VGND VPWR VPWR sky130_fd_sc_hd__decap_3
XFILLER_19_433 VGND VGND VPWR VPWR sky130_fd_sc_hd__decap_3
XFILLER_59_591 VGND VGND VPWR VPWR sky130_fd_sc_hd__decap_3
XFILLER_19_455 VGND VGND VPWR VPWR sky130_fd_sc_hd__decap_3
XFILLER_19_488 VGND VGND VPWR VPWR sky130_fd_sc_hd__decap_3
XFILLER_74_572 VGND VGND VPWR VPWR sky130_fd_sc_hd__decap_3
XTAP_TAPCELL_ROW_105_1507 VGND VPWR sky130_fd_sc_hd__tapvpwrvgnd_1
XFILLER_61_233 VGND VGND VPWR VPWR sky130_fd_sc_hd__decap_3
XFILLER_15_650 VGND VGND VPWR VPWR sky130_fd_sc_hd__decap_3
XFILLER_34_469 VGND VGND VPWR VPWR sky130_fd_sc_hd__decap_3
XFILLER_61_266 VGND VGND VPWR VPWR sky130_fd_sc_hd__decap_3
XFILLER_14_171 VGND VGND VPWR VPWR sky130_fd_sc_hd__decap_3
XFILLER_30_631 VGND VGND VPWR VPWR sky130_fd_sc_hd__decap_3
XFILLER_61_299 VGND VGND VPWR VPWR sky130_fd_sc_hd__decap_3
XTAP_TAPCELL_ROW_32_637 VGND VPWR sky130_fd_sc_hd__tapvpwrvgnd_1
X_4650_ _4440_/A _4650_/B VGND VGND VPWR VPWR _4810_/B sky130_fd_sc_hd__and2b_2
XTAP_TAPCELL_ROW_60_968 VGND VPWR sky130_fd_sc_hd__tapvpwrvgnd_1
XFILLER_30_675 VGND VGND VPWR VPWR sky130_fd_sc_hd__decap_3
X_3601_ _3427_/B _3600_/Y _3599_/A VGND VGND VPWR VPWR _4613_/B sky130_fd_sc_hd__a21oi_2
X_6320_ _6637_/A VGND VGND VPWR VPWR _6320_/Y sky130_fd_sc_hd__inv_2
X_4581_ _4581_/A _4595_/B VGND VGND VPWR VPWR _7290_/D sky130_fd_sc_hd__and2_2
XTAP_TAPCELL_ROW_12_394 VGND VPWR sky130_fd_sc_hd__tapvpwrvgnd_1
XFILLER_115_213 VGND VGND VPWR VPWR sky130_fd_sc_hd__decap_3
Xhold805 _6811_/Q VGND VGND VPWR VPWR _6811_/D sky130_fd_sc_hd__dlygate4sd3_1
Xhold816 _6931_/Q VGND VGND VPWR VPWR _6931_/D sky130_fd_sc_hd__dlygate4sd3_1
Xhold827 _6766_/Q VGND VGND VPWR VPWR _6766_/D sky130_fd_sc_hd__dlygate4sd3_1
X_3532_ _6981_/Q _3509_/Y _5642_/B _5659_/A _4471_/S VGND VGND VPWR VPWR _3621_/A
+ sky130_fd_sc_hd__a41o_2
XTAP_TAPCELL_ROW_116_1658 VGND VPWR sky130_fd_sc_hd__tapvpwrvgnd_1
XTAP_TAPCELL_ROW_116_1647 VGND VPWR sky130_fd_sc_hd__tapvpwrvgnd_1
XFILLER_89_609 VGND VGND VPWR VPWR sky130_fd_sc_hd__decap_3
Xhold838 _6942_/Q VGND VGND VPWR VPWR _6942_/D sky130_fd_sc_hd__dlygate4sd3_1
Xhold849 _7063_/Q VGND VGND VPWR VPWR _7063_/D sky130_fd_sc_hd__dlygate4sd3_1
Xmax_cap557 _3605_/Y VGND VGND VPWR VPWR _5146_/B1 sky130_fd_sc_hd__buf_2
X_3463_ _7057_/Q _4305_/B _4460_/A _3462_/X VGND VGND VPWR VPWR _3545_/A sky130_fd_sc_hd__o211ai_4
XFILLER_69_300 VGND VGND VPWR VPWR sky130_fd_sc_hd__decap_3
XFILLER_97_620 VGND VGND VPWR VPWR sky130_fd_sc_hd__decap_3
X_3394_ _3394_/A _3429_/B VGND VGND VPWR VPWR _3577_/B sky130_fd_sc_hd__or2_2
XFILLER_97_653 VGND VGND VPWR VPWR sky130_fd_sc_hd__decap_3
XFILLER_111_441 VGND VGND VPWR VPWR sky130_fd_sc_hd__decap_3
XFILLER_111_452 VGND VGND VPWR VPWR sky130_fd_sc_hd__decap_3
XFILLER_69_366 VGND VGND VPWR VPWR sky130_fd_sc_hd__decap_3
XFILLER_84_303 VGND VGND VPWR VPWR sky130_fd_sc_hd__decap_3
XFILLER_96_141 VGND VGND VPWR VPWR sky130_fd_sc_hd__decap_3
XFILLER_111_485 VGND VGND VPWR VPWR sky130_fd_sc_hd__decap_3
XFILLER_57_528 VGND VGND VPWR VPWR sky130_fd_sc_hd__decap_3
XFILLER_96_174 VGND VGND VPWR VPWR sky130_fd_sc_hd__decap_3
XFILLER_52_200 VGND VGND VPWR VPWR sky130_fd_sc_hd__decap_3
XFILLER_65_561 VGND VGND VPWR VPWR sky130_fd_sc_hd__decap_3
XFILLER_65_594 VGND VGND VPWR VPWR sky130_fd_sc_hd__decap_3
XFILLER_52_222 VGND VGND VPWR VPWR sky130_fd_sc_hd__decap_3
XFILLER_52_244 VGND VGND VPWR VPWR sky130_fd_sc_hd__decap_3
XFILLER_80_542 VGND VGND VPWR VPWR sky130_fd_sc_hd__decap_3
XFILLER_13_609 VGND VGND VPWR VPWR sky130_fd_sc_hd__decap_3
XFILLER_40_417 VGND VGND VPWR VPWR sky130_fd_sc_hd__decap_3
XFILLER_80_575 VGND VGND VPWR VPWR sky130_fd_sc_hd__decap_3
XFILLER_21_620 VGND VGND VPWR VPWR sky130_fd_sc_hd__decap_3
XFILLER_52_288 VGND VGND VPWR VPWR sky130_fd_sc_hd__decap_3
X_4917_ _4967_/A _4950_/A _4967_/B VGND VGND VPWR VPWR _4918_/B sky130_fd_sc_hd__and3_2
XFILLER_20_130 VGND VGND VPWR VPWR sky130_fd_sc_hd__fill_1
XFILLER_20_141 VGND VGND VPWR VPWR sky130_fd_sc_hd__decap_3
XFILLER_21_653 VGND VGND VPWR VPWR sky130_fd_sc_hd__decap_3
X_4848_ _4884_/A _4904_/B _4140_/X VGND VGND VPWR VPWR _4872_/B sky130_fd_sc_hd__o21ba_2
XFILLER_20_163 VGND VGND VPWR VPWR sky130_fd_sc_hd__decap_3
XFILLER_4_307 VGND VGND VPWR VPWR sky130_fd_sc_hd__fill_1
X_4779_ _4779_/A _4827_/B VGND VGND VPWR VPWR _4779_/X sky130_fd_sc_hd__or2_2
XFILLER_4_318 VGND VGND VPWR VPWR sky130_fd_sc_hd__decap_3
X_6518_ _6614_/A VGND VGND VPWR VPWR _6518_/Y sky130_fd_sc_hd__inv_2
X_6449_ _6614_/A VGND VGND VPWR VPWR _6449_/Y sky130_fd_sc_hd__inv_2
XFILLER_0_502 VGND VGND VPWR VPWR sky130_fd_sc_hd__fill_2
XFILLER_79_119 VGND VGND VPWR VPWR sky130_fd_sc_hd__decap_3
XFILLER_0_524 VGND VGND VPWR VPWR sky130_fd_sc_hd__decap_3
XFILLER_0_546 VGND VGND VPWR VPWR sky130_fd_sc_hd__decap_3
XFILLER_88_631 VGND VGND VPWR VPWR sky130_fd_sc_hd__decap_3
XFILLER_87_130 VGND VGND VPWR VPWR sky130_fd_sc_hd__decap_3
XFILLER_88_675 VGND VGND VPWR VPWR sky130_fd_sc_hd__decap_3
XFILLER_102_474 VGND VGND VPWR VPWR sky130_fd_sc_hd__fill_2
XFILLER_57_45 VGND VGND VPWR VPWR sky130_fd_sc_hd__decap_3
XFILLER_28_230 VGND VGND VPWR VPWR sky130_fd_sc_hd__decap_3
XFILLER_75_347 VGND VGND VPWR VPWR sky130_fd_sc_hd__fill_1
XFILLER_75_369 VGND VGND VPWR VPWR sky130_fd_sc_hd__decap_3
XFILLER_56_561 VGND VGND VPWR VPWR sky130_fd_sc_hd__decap_3
XFILLER_73_11 VGND VGND VPWR VPWR sky130_fd_sc_hd__decap_3
XFILLER_90_317 VGND VGND VPWR VPWR sky130_fd_sc_hd__decap_3
XFILLER_113_84 VGND VGND VPWR VPWR sky130_fd_sc_hd__decap_3
XFILLER_71_542 VGND VGND VPWR VPWR sky130_fd_sc_hd__fill_1
XFILLER_43_266 VGND VGND VPWR VPWR sky130_fd_sc_hd__decap_3
XFILLER_71_564 VGND VGND VPWR VPWR sky130_fd_sc_hd__decap_3
XFILLER_12_631 VGND VGND VPWR VPWR sky130_fd_sc_hd__decap_3
XFILLER_31_439 VGND VGND VPWR VPWR sky130_fd_sc_hd__decap_3
XFILLER_43_299 VGND VGND VPWR VPWR sky130_fd_sc_hd__decap_3
XFILLER_71_597 VGND VGND VPWR VPWR sky130_fd_sc_hd__decap_3
XFILLER_8_613 VGND VGND VPWR VPWR sky130_fd_sc_hd__decap_3
XTAP_TAPCELL_ROW_100_1448 VGND VPWR sky130_fd_sc_hd__tapvpwrvgnd_1
XFILLER_12_675 VGND VGND VPWR VPWR sky130_fd_sc_hd__decap_3
XFILLER_8_657 VGND VGND VPWR VPWR sky130_fd_sc_hd__decap_3
XFILLER_22_81 VGND VGND VPWR VPWR sky130_fd_sc_hd__decap_3
XFILLER_7_189 VGND VGND VPWR VPWR sky130_fd_sc_hd__decap_3
XFILLER_112_205 VGND VGND VPWR VPWR sky130_fd_sc_hd__decap_3
XFILLER_3_340 VGND VGND VPWR VPWR sky130_fd_sc_hd__fill_1
XFILLER_98_85 VGND VGND VPWR VPWR sky130_fd_sc_hd__fill_1
XFILLER_98_74 VGND VGND VPWR VPWR sky130_fd_sc_hd__fill_1
XFILLER_112_227 VGND VGND VPWR VPWR sky130_fd_sc_hd__decap_3
XFILLER_79_620 VGND VGND VPWR VPWR sky130_fd_sc_hd__decap_3
XFILLER_78_130 VGND VGND VPWR VPWR sky130_fd_sc_hd__decap_3
XFILLER_78_141 VGND VGND VPWR VPWR sky130_fd_sc_hd__decap_3
XFILLER_79_653 VGND VGND VPWR VPWR sky130_fd_sc_hd__decap_3
XFILLER_94_601 VGND VGND VPWR VPWR sky130_fd_sc_hd__decap_3
XTAP_TAPCELL_ROW_111_1588 VGND VPWR sky130_fd_sc_hd__tapvpwrvgnd_1
XFILLER_78_174 VGND VGND VPWR VPWR sky130_fd_sc_hd__decap_3
XFILLER_94_634 VGND VGND VPWR VPWR sky130_fd_sc_hd__decap_3
XFILLER_94_645 VGND VGND VPWR VPWR sky130_fd_sc_hd__decap_3
XFILLER_94_678 VGND VGND VPWR VPWR sky130_fd_sc_hd__decap_3
XFILLER_47_561 VGND VGND VPWR VPWR sky130_fd_sc_hd__decap_3
XFILLER_93_177 VGND VGND VPWR VPWR sky130_fd_sc_hd__decap_3
XFILLER_47_594 VGND VGND VPWR VPWR sky130_fd_sc_hd__decap_3
XFILLER_62_520 VGND VGND VPWR VPWR sky130_fd_sc_hd__decap_3
XFILLER_93_199 VGND VGND VPWR VPWR sky130_fd_sc_hd__decap_3
XTAP_TAPCELL_ROW_66_1045 VGND VPWR sky130_fd_sc_hd__tapvpwrvgnd_1
XFILLER_62_575 VGND VGND VPWR VPWR sky130_fd_sc_hd__decap_3
XTAP_TAPCELL_ROW_17_453 VGND VPWR sky130_fd_sc_hd__tapvpwrvgnd_1
XFILLER_34_288 VGND VGND VPWR VPWR sky130_fd_sc_hd__decap_3
XTAP_TAPCELL_ROW_45_795 VGND VPWR sky130_fd_sc_hd__tapvpwrvgnd_1
XPHY_EDGE_ROW_22_Left_139 VGND VGND VPWR VPWR sky130_fd_sc_hd__decap_3
X_4702_ _6991_/Q _5026_/A VGND VGND VPWR VPWR _5001_/A sky130_fd_sc_hd__and2_2
XFILLER_30_483 VGND VGND VPWR VPWR sky130_fd_sc_hd__decap_3
X_5682_ _7347_/Q _5682_/A1 _5699_/S VGND VGND VPWR VPWR _6691_/D sky130_fd_sc_hd__mux2_2
X_4633_ _4633_/A _4903_/A _4845_/A _4890_/B VGND VGND VPWR VPWR _4633_/X sky130_fd_sc_hd__or4_2
XFILLER_116_511 VGND VGND VPWR VPWR sky130_fd_sc_hd__fill_2
X_7352_ _7355_/CLK _7352_/D _6632_/Y VGND VGND VPWR VPWR _7352_/Q sky130_fd_sc_hd__dfrtp_2
Xhold602 _6970_/Q VGND VGND VPWR VPWR _6970_/D sky130_fd_sc_hd__dlygate4sd3_1
XFILLER_116_533 VGND VGND VPWR VPWR sky130_fd_sc_hd__fill_2
XFILLER_116_555 VGND VGND VPWR VPWR sky130_fd_sc_hd__decap_3
X_7283_ _7317_/CLK _7283_/D _6563_/Y VGND VGND VPWR VPWR _7283_/Q sky130_fd_sc_hd__dfrtp_2
Xhold613 _6721_/Q VGND VGND VPWR VPWR _6721_/D sky130_fd_sc_hd__dlygate4sd3_1
Xhold624 _6750_/Q VGND VGND VPWR VPWR _6750_/D sky130_fd_sc_hd__dlygate4sd3_1
Xhold635 _6907_/Q VGND VGND VPWR VPWR _6907_/D sky130_fd_sc_hd__dlygate4sd3_1
X_6303_ _6618_/A VGND VGND VPWR VPWR _6303_/Y sky130_fd_sc_hd__inv_2
X_3515_ _3509_/Y _3510_/X _4285_/B1 VGND VGND VPWR VPWR _4938_/A sky130_fd_sc_hd__a21o_2
XTAP_TAPCELL_ROW_77_1174 VGND VPWR sky130_fd_sc_hd__tapvpwrvgnd_1
XFILLER_103_205 VGND VGND VPWR VPWR sky130_fd_sc_hd__decap_3
XFILLER_89_417 VGND VGND VPWR VPWR sky130_fd_sc_hd__decap_3
Xhold646 _6813_/Q VGND VGND VPWR VPWR _6813_/D sky130_fd_sc_hd__dlygate4sd3_1
Xhold657 _6870_/Q VGND VGND VPWR VPWR _6870_/D sky130_fd_sc_hd__dlygate4sd3_1
Xhold668 _6946_/Q VGND VGND VPWR VPWR _6946_/D sky130_fd_sc_hd__dlygate4sd3_1
Xhold679 _6936_/Q VGND VGND VPWR VPWR _6936_/D sky130_fd_sc_hd__dlygate4sd3_1
X_4495_ _4495_/A0 _7300_/Q _4505_/S VGND VGND VPWR VPWR _7332_/D sky130_fd_sc_hd__mux2_2
XPHY_EDGE_ROW_31_Left_148 VGND VGND VPWR VPWR sky130_fd_sc_hd__decap_3
XFILLER_89_439 VGND VGND VPWR VPWR sky130_fd_sc_hd__decap_3
XTAP_TAPCELL_ROW_90_1330 VGND VPWR sky130_fd_sc_hd__tapvpwrvgnd_1
X_3377_ _3394_/A _3429_/A _5641_/A _5161_/A VGND VGND VPWR VPWR _3377_/X sky130_fd_sc_hd__and4bb_4
XFILLER_57_325 VGND VGND VPWR VPWR sky130_fd_sc_hd__decap_3
XFILLER_85_612 VGND VGND VPWR VPWR sky130_fd_sc_hd__decap_3
XFILLER_85_623 VGND VGND VPWR VPWR sky130_fd_sc_hd__decap_3
XFILLER_97_494 VGND VGND VPWR VPWR sky130_fd_sc_hd__decap_3
X_5116_ _5110_/Y _5111_/X _5115_/X VGND VGND VPWR VPWR _5116_/Y sky130_fd_sc_hd__o21ai_2
XFILLER_57_369 VGND VGND VPWR VPWR sky130_fd_sc_hd__fill_2
XFILLER_69_196 VGND VGND VPWR VPWR sky130_fd_sc_hd__decap_3
XFILLER_85_656 VGND VGND VPWR VPWR sky130_fd_sc_hd__decap_3
X_5047_ _5114_/B _4617_/B _4617_/C _5100_/A VGND VGND VPWR VPWR _5047_/Y sky130_fd_sc_hd__o31ai_1
XFILLER_38_572 VGND VGND VPWR VPWR sky130_fd_sc_hd__decap_3
XFILLER_84_166 VGND VGND VPWR VPWR sky130_fd_sc_hd__decap_3
XFILLER_25_211 VGND VGND VPWR VPWR sky130_fd_sc_hd__fill_1
XFILLER_65_391 VGND VGND VPWR VPWR sky130_fd_sc_hd__fill_1
XFILLER_25_266 VGND VGND VPWR VPWR sky130_fd_sc_hd__decap_3
XFILLER_53_564 VGND VGND VPWR VPWR sky130_fd_sc_hd__decap_3
X_6998_ _7144_/CLK _6998_/D _6278_/Y VGND VGND VPWR VPWR _6998_/Q sky130_fd_sc_hd__dfrtp_2
XPHY_EDGE_ROW_40_Left_157 VGND VGND VPWR VPWR sky130_fd_sc_hd__decap_3
XFILLER_13_417 VGND VGND VPWR VPWR sky130_fd_sc_hd__decap_3
XFILLER_25_277 VGND VGND VPWR VPWR sky130_fd_sc_hd__decap_3
XFILLER_25_299 VGND VGND VPWR VPWR sky130_fd_sc_hd__decap_3
XFILLER_53_597 VGND VGND VPWR VPWR sky130_fd_sc_hd__decap_3
XFILLER_107_500 VGND VGND VPWR VPWR sky130_fd_sc_hd__decap_3
XFILLER_107_511 VGND VGND VPWR VPWR sky130_fd_sc_hd__decap_3
XFILLER_5_638 VGND VGND VPWR VPWR sky130_fd_sc_hd__decap_3
XFILLER_104_3 VGND VGND VPWR VPWR sky130_fd_sc_hd__decap_3
XFILLER_107_544 VGND VGND VPWR VPWR sky130_fd_sc_hd__decap_3
XFILLER_4_137 VGND VGND VPWR VPWR sky130_fd_sc_hd__decap_3
XFILLER_107_588 VGND VGND VPWR VPWR sky130_fd_sc_hd__decap_3
XFILLER_0_354 VGND VGND VPWR VPWR sky130_fd_sc_hd__fill_2
XFILLER_76_601 VGND VGND VPWR VPWR sky130_fd_sc_hd__decap_3
XFILLER_95_409 VGND VGND VPWR VPWR sky130_fd_sc_hd__decap_3
XFILLER_0_365 VGND VGND VPWR VPWR sky130_fd_sc_hd__decap_3
XFILLER_68_99 VGND VGND VPWR VPWR sky130_fd_sc_hd__decap_3
XFILLER_75_111 VGND VGND VPWR VPWR sky130_fd_sc_hd__fill_1
XFILLER_76_634 VGND VGND VPWR VPWR sky130_fd_sc_hd__decap_3
XFILLER_76_645 VGND VGND VPWR VPWR sky130_fd_sc_hd__decap_3
XFILLER_76_678 VGND VGND VPWR VPWR sky130_fd_sc_hd__decap_3
XFILLER_84_32 VGND VGND VPWR VPWR sky130_fd_sc_hd__fill_2
XFILLER_29_561 VGND VGND VPWR VPWR sky130_fd_sc_hd__decap_3
XFILLER_63_306 VGND VGND VPWR VPWR sky130_fd_sc_hd__decap_3
XFILLER_75_155 VGND VGND VPWR VPWR sky130_fd_sc_hd__decap_3
XFILLER_91_615 VGND VGND VPWR VPWR sky130_fd_sc_hd__fill_1
XFILLER_91_626 VGND VGND VPWR VPWR sky130_fd_sc_hd__decap_3
XFILLER_16_200 VGND VGND VPWR VPWR sky130_fd_sc_hd__decap_3
XFILLER_29_594 VGND VGND VPWR VPWR sky130_fd_sc_hd__decap_3
XFILLER_44_531 VGND VGND VPWR VPWR sky130_fd_sc_hd__fill_1
XFILLER_91_659 VGND VGND VPWR VPWR sky130_fd_sc_hd__decap_3
Xplace328 _4205_/A VGND VGND VPWR VPWR _4432_/B1 sky130_fd_sc_hd__buf_2
Xplace317 _4591_/B VGND VGND VPWR VPWR _4577_/B sky130_fd_sc_hd__buf_2
Xplace306 _4186_/Y VGND VGND VPWR VPWR _4950_/A sky130_fd_sc_hd__buf_2
XFILLER_44_575 VGND VGND VPWR VPWR sky130_fd_sc_hd__decap_3
Xplace339 _4421_/A2 VGND VGND VPWR VPWR _4430_/A2 sky130_fd_sc_hd__buf_2
XFILLER_31_214 VGND VGND VPWR VPWR sky130_fd_sc_hd__fill_1
XFILLER_31_225 VGND VGND VPWR VPWR sky130_fd_sc_hd__fill_1
XFILLER_90_9 VGND VGND VPWR VPWR sky130_fd_sc_hd__decap_3
XTAP_TAPCELL_ROW_42_754 VGND VPWR sky130_fd_sc_hd__tapvpwrvgnd_1
XTAP_TAPCELL_ROW_14_423 VGND VPWR sky130_fd_sc_hd__tapvpwrvgnd_1
XFILLER_8_421 VGND VGND VPWR VPWR sky130_fd_sc_hd__decap_3
XFILLER_69_6 VGND VGND VPWR VPWR sky130_fd_sc_hd__decap_3
XTAP_TAPCELL_ROW_113_1606 VGND VPWR sky130_fd_sc_hd__tapvpwrvgnd_1
XFILLER_113_503 VGND VGND VPWR VPWR sky130_fd_sc_hd__fill_1
XFILLER_113_514 VGND VGND VPWR VPWR sky130_fd_sc_hd__decap_3
XFILLER_4_660 VGND VGND VPWR VPWR sky130_fd_sc_hd__decap_3
X_3300_ _3331_/B VGND VGND VPWR VPWR _4467_/A sky130_fd_sc_hd__inv_2
XFILLER_113_547 VGND VGND VPWR VPWR sky130_fd_sc_hd__decap_3
X_4280_ _7222_/Q _4349_/B1 _3366_/X _7158_/Q _4279_/X VGND VGND VPWR VPWR _4280_/X
+ sky130_fd_sc_hd__a221o_2
XFILLER_100_208 VGND VGND VPWR VPWR sky130_fd_sc_hd__decap_3
XFILLER_66_100 VGND VGND VPWR VPWR sky130_fd_sc_hd__decap_3
XFILLER_67_612 VGND VGND VPWR VPWR sky130_fd_sc_hd__decap_3
XFILLER_67_623 VGND VGND VPWR VPWR sky130_fd_sc_hd__decap_3
XFILLER_67_656 VGND VGND VPWR VPWR sky130_fd_sc_hd__decap_3
XFILLER_82_604 VGND VGND VPWR VPWR sky130_fd_sc_hd__decap_3
XFILLER_82_637 VGND VGND VPWR VPWR sky130_fd_sc_hd__decap_3
XFILLER_35_520 VGND VGND VPWR VPWR sky130_fd_sc_hd__fill_1
XFILLER_82_648 VGND VGND VPWR VPWR sky130_fd_sc_hd__decap_3
X_6921_ _7378_/CLK _6921_/D VGND VGND VPWR VPWR _6921_/Q sky130_fd_sc_hd__dfxtp_2
XFILLER_35_564 VGND VGND VPWR VPWR sky130_fd_sc_hd__decap_3
XFILLER_50_501 VGND VGND VPWR VPWR sky130_fd_sc_hd__decap_3
XFILLER_81_169 VGND VGND VPWR VPWR sky130_fd_sc_hd__decap_3
X_6852_ _6959_/CLK _6852_/D VGND VGND VPWR VPWR _6852_/Q sky130_fd_sc_hd__dfxtp_2
XFILLER_22_214 VGND VGND VPWR VPWR sky130_fd_sc_hd__decap_3
XFILLER_35_597 VGND VGND VPWR VPWR sky130_fd_sc_hd__decap_3
XFILLER_62_394 VGND VGND VPWR VPWR sky130_fd_sc_hd__decap_3
XFILLER_90_681 VGND VGND VPWR VPWR sky130_fd_sc_hd__decap_3
Xfanout18 fanout38/A VGND VGND VPWR VPWR _6662_/A sky130_fd_sc_hd__clkdlybuf4s25_1
Xfanout29 _6603_/A VGND VGND VPWR VPWR _6635_/A sky130_fd_sc_hd__buf_2
XFILLER_22_247 VGND VGND VPWR VPWR sky130_fd_sc_hd__decap_3
X_6783_ _6943_/CLK _6783_/D VGND VGND VPWR VPWR _6783_/Q sky130_fd_sc_hd__dfxtp_2
XFILLER_13_28 VGND VGND VPWR VPWR sky130_fd_sc_hd__fill_1
XFILLER_50_578 VGND VGND VPWR VPWR sky130_fd_sc_hd__decap_3
XFILLER_50_589 VGND VGND VPWR VPWR sky130_fd_sc_hd__decap_3
XFILLER_30_280 VGND VGND VPWR VPWR sky130_fd_sc_hd__decap_3
X_5665_ _5665_/A _5665_/B _5665_/C _5665_/D VGND VGND VPWR VPWR _5666_/B sky130_fd_sc_hd__and4_2
XTAP_TAPCELL_ROW_79_1203 VGND VPWR sky130_fd_sc_hd__tapvpwrvgnd_1
X_7404_ _7404_/CLK _7404_/D _6684_/Y VGND VGND VPWR VPWR _7404_/Q sky130_fd_sc_hd__dfrtp_2
X_4616_ _3547_/A _3547_/B _4614_/X _4615_/Y VGND VGND VPWR VPWR _4617_/C sky130_fd_sc_hd__a31o_2
X_7335_ _7405_/CLK _7335_/D _6615_/Y VGND VGND VPWR VPWR _7335_/Q sky130_fd_sc_hd__dfrtp_2
XPHY_EDGE_ROW_111_Right_111 VGND VGND VPWR VPWR sky130_fd_sc_hd__decap_3
XFILLER_116_374 VGND VGND VPWR VPWR sky130_fd_sc_hd__decap_3
XFILLER_2_619 VGND VGND VPWR VPWR sky130_fd_sc_hd__decap_3
XFILLER_104_525 VGND VGND VPWR VPWR sky130_fd_sc_hd__decap_3
XFILLER_104_536 VGND VGND VPWR VPWR sky130_fd_sc_hd__decap_3
XFILLER_116_396 VGND VGND VPWR VPWR sky130_fd_sc_hd__decap_3
X_7266_ _7362_/CLK _7266_/D _6546_/Y VGND VGND VPWR VPWR _7266_/Q sky130_fd_sc_hd__dfrtp_2
X_4478_ _4478_/A0 _4544_/A _4478_/S VGND VGND VPWR VPWR _7340_/D sky130_fd_sc_hd__mux2_2
XFILLER_104_569 VGND VGND VPWR VPWR sky130_fd_sc_hd__decap_3
XFILLER_58_601 VGND VGND VPWR VPWR sky130_fd_sc_hd__decap_3
X_7197_ _7392_/CLK _7197_/D _6477_/Y VGND VGND VPWR VPWR _7197_/Q sky130_fd_sc_hd__dfrtp_2
X_3429_ _3429_/A _3429_/B VGND VGND VPWR VPWR _3590_/A sky130_fd_sc_hd__or2_2
XFILLER_57_100 VGND VGND VPWR VPWR sky130_fd_sc_hd__fill_2
XFILLER_58_634 VGND VGND VPWR VPWR sky130_fd_sc_hd__decap_3
XFILLER_85_420 VGND VGND VPWR VPWR sky130_fd_sc_hd__fill_2
XFILLER_58_645 VGND VGND VPWR VPWR sky130_fd_sc_hd__decap_3
Xhold1110 _7166_/Q VGND VGND VPWR VPWR _5329_/A0 sky130_fd_sc_hd__dlygate4sd3_1
Xhold1121 _7172_/Q VGND VGND VPWR VPWR _5317_/A0 sky130_fd_sc_hd__dlygate4sd3_1
Xhold1132 _7130_/Q VGND VGND VPWR VPWR _5407_/A0 sky130_fd_sc_hd__dlygate4sd3_1
XFILLER_45_306 VGND VGND VPWR VPWR sky130_fd_sc_hd__decap_3
XFILLER_58_678 VGND VGND VPWR VPWR sky130_fd_sc_hd__decap_3
XFILLER_72_103 VGND VGND VPWR VPWR sky130_fd_sc_hd__decap_3
XFILLER_73_615 VGND VGND VPWR VPWR sky130_fd_sc_hd__fill_1
XFILLER_73_626 VGND VGND VPWR VPWR sky130_fd_sc_hd__decap_3
Xhold1143 _7140_/Q VGND VGND VPWR VPWR _5386_/A0 sky130_fd_sc_hd__dlygate4sd3_1
Xhold1154 _7304_/Q VGND VGND VPWR VPWR _4552_/A sky130_fd_sc_hd__dlygate4sd3_1
Xhold1165 _7376_/Q VGND VGND VPWR VPWR _3924_/A1 sky130_fd_sc_hd__dlygate4sd3_1
Xhold1176 _7149_/Q VGND VGND VPWR VPWR _5367_/A0 sky130_fd_sc_hd__dlygate4sd3_1
XFILLER_73_659 VGND VGND VPWR VPWR sky130_fd_sc_hd__decap_3
Xhold1187 _7122_/Q VGND VGND VPWR VPWR _5423_/A0 sky130_fd_sc_hd__dlygate4sd3_1
Xhold1198 _7157_/Q VGND VGND VPWR VPWR _5348_/A0 sky130_fd_sc_hd__dlygate4sd3_1
XFILLER_60_309 VGND VGND VPWR VPWR sky130_fd_sc_hd__decap_3
XFILLER_72_147 VGND VGND VPWR VPWR sky130_fd_sc_hd__decap_3
XFILLER_72_169 VGND VGND VPWR VPWR sky130_fd_sc_hd__decap_3
XFILLER_13_214 VGND VGND VPWR VPWR sky130_fd_sc_hd__fill_2
XFILLER_13_225 VGND VGND VPWR VPWR sky130_fd_sc_hd__decap_3
XFILLER_26_586 VGND VGND VPWR VPWR sky130_fd_sc_hd__fill_2
XFILLER_53_361 VGND VGND VPWR VPWR sky130_fd_sc_hd__decap_3
XFILLER_110_41 VGND VGND VPWR VPWR sky130_fd_sc_hd__decap_3
XFILLER_13_258 VGND VGND VPWR VPWR sky130_fd_sc_hd__decap_3
XFILLER_41_545 VGND VGND VPWR VPWR sky130_fd_sc_hd__decap_3
XFILLER_41_567 VGND VGND VPWR VPWR sky130_fd_sc_hd__decap_3
XFILLER_80_180 VGND VGND VPWR VPWR sky130_fd_sc_hd__decap_3
XFILLER_9_207 VGND VGND VPWR VPWR sky130_fd_sc_hd__decap_3
XFILLER_110_74 VGND VGND VPWR VPWR sky130_fd_sc_hd__decap_3
XFILLER_110_85 VGND VGND VPWR VPWR sky130_fd_sc_hd__decap_3
XFILLER_5_435 VGND VGND VPWR VPWR sky130_fd_sc_hd__decap_3
XFILLER_107_374 VGND VGND VPWR VPWR sky130_fd_sc_hd__decap_3
XFILLER_107_396 VGND VGND VPWR VPWR sky130_fd_sc_hd__decap_3
XFILLER_1_641 VGND VGND VPWR VPWR sky130_fd_sc_hd__decap_3
XFILLER_68_409 VGND VGND VPWR VPWR sky130_fd_sc_hd__decap_3
XFILLER_0_162 VGND VGND VPWR VPWR sky130_fd_sc_hd__decap_3
XFILLER_110_528 VGND VGND VPWR VPWR sky130_fd_sc_hd__decap_3
XFILLER_110_539 VGND VGND VPWR VPWR sky130_fd_sc_hd__decap_3
XFILLER_1_685 VGND VGND VPWR VPWR sky130_fd_sc_hd__decap_3
XFILLER_49_612 VGND VGND VPWR VPWR sky130_fd_sc_hd__decap_3
XFILLER_49_623 VGND VGND VPWR VPWR sky130_fd_sc_hd__decap_3
XFILLER_95_20 VGND VGND VPWR VPWR sky130_fd_sc_hd__decap_3
XFILLER_95_217 VGND VGND VPWR VPWR sky130_fd_sc_hd__fill_1
XFILLER_103_591 VGND VGND VPWR VPWR sky130_fd_sc_hd__decap_3
XFILLER_49_656 VGND VGND VPWR VPWR sky130_fd_sc_hd__decap_3
XFILLER_95_53 VGND VGND VPWR VPWR sky130_fd_sc_hd__decap_3
XFILLER_64_604 VGND VGND VPWR VPWR sky130_fd_sc_hd__decap_3
XTAP_TAPCELL_ROW_47_813 VGND VPWR sky130_fd_sc_hd__tapvpwrvgnd_1
XFILLER_17_520 VGND VGND VPWR VPWR sky130_fd_sc_hd__decap_3
XFILLER_29_391 VGND VGND VPWR VPWR sky130_fd_sc_hd__fill_1
XFILLER_64_637 VGND VGND VPWR VPWR sky130_fd_sc_hd__decap_3
XFILLER_64_648 VGND VGND VPWR VPWR sky130_fd_sc_hd__decap_3
XFILLER_17_553 VGND VGND VPWR VPWR sky130_fd_sc_hd__decap_3
XFILLER_17_564 VGND VGND VPWR VPWR sky130_fd_sc_hd__decap_3
XFILLER_17_597 VGND VGND VPWR VPWR sky130_fd_sc_hd__decap_3
XFILLER_44_361 VGND VGND VPWR VPWR sky130_fd_sc_hd__decap_3
XFILLER_44_383 VGND VGND VPWR VPWR sky130_fd_sc_hd__decap_3
XFILLER_72_681 VGND VGND VPWR VPWR sky130_fd_sc_hd__decap_3
XTAP_TAPCELL_ROW_63_1004 VGND VPWR sky130_fd_sc_hd__tapvpwrvgnd_1
XTAP_TAPCELL_ROW_27_570 VGND VPWR sky130_fd_sc_hd__tapvpwrvgnd_1
XFILLER_32_567 VGND VGND VPWR VPWR sky130_fd_sc_hd__decap_3
XTAP_TAPCELL_ROW_27_581 VGND VPWR sky130_fd_sc_hd__tapvpwrvgnd_1
XFILLER_32_589 VGND VGND VPWR VPWR sky130_fd_sc_hd__decap_3
X_3780_ _6967_/Q _3886_/A2 _3891_/A2 _6955_/Q VGND VGND VPWR VPWR _3780_/X sky130_fd_sc_hd__a22o_2
XFILLER_12_291 VGND VGND VPWR VPWR sky130_fd_sc_hd__decap_3
XFILLER_8_251 VGND VGND VPWR VPWR sky130_fd_sc_hd__fill_1
X_4401_ _7274_/Q _4401_/A2 _4430_/A2 _7242_/Q _4400_/X VGND VGND VPWR VPWR _4401_/X
+ sky130_fd_sc_hd__a221o_2
Xoutput526 _6994_/Q VGND VGND VPWR VPWR pc_out[17] sky130_fd_sc_hd__clkdlybuf4s25_1
Xoutput515 _5229_/B VGND VGND VPWR VPWR instruction_out[7] sky130_fd_sc_hd__clkdlybuf4s25_1
Xoutput504 _4528_/B VGND VGND VPWR VPWR instruction_out[24] sky130_fd_sc_hd__clkdlybuf4s25_1
X_5381_ _5381_/A0 _4864_/X _5383_/S VGND VGND VPWR VPWR _7142_/D sky130_fd_sc_hd__mux2_2
XFILLER_99_501 VGND VGND VPWR VPWR sky130_fd_sc_hd__decap_3
XFILLER_113_300 VGND VGND VPWR VPWR sky130_fd_sc_hd__decap_3
X_7120_ _7344_/CLK _7120_/D _6400_/Y VGND VGND VPWR VPWR _7120_/Q sky130_fd_sc_hd__dfrtp_2
Xoutput548 _6985_/Q VGND VGND VPWR VPWR pc_out[8] sky130_fd_sc_hd__clkdlybuf4s25_1
Xoutput537 _7004_/Q VGND VGND VPWR VPWR pc_out[27] sky130_fd_sc_hd__clkdlybuf4s25_1
X_4332_ _7191_/Q _3996_/S _4346_/B1 _7383_/Q _4331_/X VGND VGND VPWR VPWR _4332_/X
+ sky130_fd_sc_hd__a221o_2
XTAP_TAPCELL_ROW_74_1144 VGND VPWR sky130_fd_sc_hd__tapvpwrvgnd_1
XFILLER_99_523 VGND VGND VPWR VPWR sky130_fd_sc_hd__decap_3
XFILLER_113_366 VGND VGND VPWR VPWR sky130_fd_sc_hd__decap_3
XFILLER_59_409 VGND VGND VPWR VPWR sky130_fd_sc_hd__decap_3
X_7051_ _7144_/CLK _7051_/D _6331_/Y VGND VGND VPWR VPWR _7051_/Q sky130_fd_sc_hd__dfrtp_2
X_4263_ _7134_/Q _4420_/B1 _4261_/X _4262_/X VGND VGND VPWR VPWR _4264_/B sky130_fd_sc_hd__a211o_2
XFILLER_99_567 VGND VGND VPWR VPWR sky130_fd_sc_hd__decap_3
XFILLER_99_556 VGND VGND VPWR VPWR sky130_fd_sc_hd__decap_3
XFILLER_101_517 VGND VGND VPWR VPWR sky130_fd_sc_hd__decap_3
XFILLER_113_399 VGND VGND VPWR VPWR sky130_fd_sc_hd__decap_3
XFILLER_86_206 VGND VGND VPWR VPWR sky130_fd_sc_hd__decap_3
XFILLER_86_239 VGND VGND VPWR VPWR sky130_fd_sc_hd__decap_3
XPHY_EDGE_ROW_105_Left_222 VGND VGND VPWR VPWR sky130_fd_sc_hd__decap_3
XFILLER_39_133 VGND VGND VPWR VPWR sky130_fd_sc_hd__fill_1
XFILLER_67_431 VGND VGND VPWR VPWR sky130_fd_sc_hd__decap_3
X_4194_ _7231_/Q _4414_/A2 _4422_/A2 _7017_/Q _4193_/X VGND VGND VPWR VPWR _4194_/X
+ sky130_fd_sc_hd__a221o_2
XFILLER_27_317 VGND VGND VPWR VPWR sky130_fd_sc_hd__decap_3
XFILLER_55_615 VGND VGND VPWR VPWR sky130_fd_sc_hd__fill_1
XFILLER_55_626 VGND VGND VPWR VPWR sky130_fd_sc_hd__decap_3
XFILLER_54_136 VGND VGND VPWR VPWR sky130_fd_sc_hd__decap_3
XFILLER_55_659 VGND VGND VPWR VPWR sky130_fd_sc_hd__decap_3
XFILLER_82_445 VGND VGND VPWR VPWR sky130_fd_sc_hd__decap_3
XFILLER_54_158 VGND VGND VPWR VPWR sky130_fd_sc_hd__decap_3
XFILLER_70_607 VGND VGND VPWR VPWR sky130_fd_sc_hd__decap_3
X_6904_ _6966_/CLK _6904_/D VGND VGND VPWR VPWR _6904_/Q sky130_fd_sc_hd__dfxtp_2
XFILLER_35_361 VGND VGND VPWR VPWR sky130_fd_sc_hd__decap_3
XTAP_TAPCELL_ROW_85_1273 VGND VPWR sky130_fd_sc_hd__tapvpwrvgnd_1
XFILLER_50_331 VGND VGND VPWR VPWR sky130_fd_sc_hd__decap_3
X_6835_ _6970_/CLK _6835_/D VGND VGND VPWR VPWR _6835_/Q sky130_fd_sc_hd__dfxtp_2
XFILLER_10_206 VGND VGND VPWR VPWR sky130_fd_sc_hd__decap_3
XFILLER_23_567 VGND VGND VPWR VPWR sky130_fd_sc_hd__decap_3
X_6766_ _6968_/CLK _6766_/D VGND VGND VPWR VPWR _6766_/Q sky130_fd_sc_hd__dfxtp_2
XPHY_EDGE_ROW_114_Left_231 VGND VGND VPWR VPWR sky130_fd_sc_hd__decap_3
XFILLER_109_606 VGND VGND VPWR VPWR sky130_fd_sc_hd__decap_3
XFILLER_50_386 VGND VGND VPWR VPWR sky130_fd_sc_hd__fill_1
X_5717_ _7364_/Q hold918/X _5737_/S VGND VGND VPWR VPWR _6708_/D sky130_fd_sc_hd__mux2_2
XFILLER_109_617 VGND VGND VPWR VPWR sky130_fd_sc_hd__decap_3
XFILLER_40_26 VGND VGND VPWR VPWR sky130_fd_sc_hd__fill_2
X_6697_ _6966_/CLK _6697_/D VGND VGND VPWR VPWR _6697_/Q sky130_fd_sc_hd__dfxtp_2
XFILLER_108_138 VGND VGND VPWR VPWR sky130_fd_sc_hd__fill_2
XFILLER_40_37 VGND VGND VPWR VPWR sky130_fd_sc_hd__decap_3
X_5648_ _5648_/A _5648_/B VGND VGND VPWR VPWR _5649_/A sky130_fd_sc_hd__or2_2
X_5579_ _5579_/A0 _5045_/X _5593_/B VGND VGND VPWR VPWR _7039_/D sky130_fd_sc_hd__mux2_2
X_7318_ _7350_/CLK _7318_/D _6598_/Y VGND VGND VPWR VPWR _7318_/Q sky130_fd_sc_hd__dfrtp_2
XFILLER_104_333 VGND VGND VPWR VPWR sky130_fd_sc_hd__decap_3
X_7249_ _7351_/CLK _7249_/D _6529_/Y VGND VGND VPWR VPWR _7249_/Q sky130_fd_sc_hd__dfrtp_2
XFILLER_104_377 VGND VGND VPWR VPWR sky130_fd_sc_hd__fill_2
XFILLER_105_30 VGND VGND VPWR VPWR sky130_fd_sc_hd__decap_3
XFILLER_100_572 VGND VGND VPWR VPWR sky130_fd_sc_hd__decap_3
XFILLER_105_63 VGND VGND VPWR VPWR sky130_fd_sc_hd__decap_3
XFILLER_18_306 VGND VGND VPWR VPWR sky130_fd_sc_hd__fill_2
XFILLER_18_317 VGND VGND VPWR VPWR sky130_fd_sc_hd__fill_2
XFILLER_46_604 VGND VGND VPWR VPWR sky130_fd_sc_hd__decap_3
XFILLER_58_453 VGND VGND VPWR VPWR sky130_fd_sc_hd__decap_3
XFILLER_65_12 VGND VGND VPWR VPWR sky130_fd_sc_hd__decap_3
XFILLER_46_637 VGND VGND VPWR VPWR sky130_fd_sc_hd__decap_3
XFILLER_46_648 VGND VGND VPWR VPWR sky130_fd_sc_hd__decap_3
XFILLER_26_350 VGND VGND VPWR VPWR sky130_fd_sc_hd__decap_3
XFILLER_54_681 VGND VGND VPWR VPWR sky130_fd_sc_hd__decap_3
XFILLER_61_629 VGND VGND VPWR VPWR sky130_fd_sc_hd__decap_3
XFILLER_14_545 VGND VGND VPWR VPWR sky130_fd_sc_hd__decap_3
XFILLER_41_342 VGND VGND VPWR VPWR sky130_fd_sc_hd__decap_3
XFILLER_81_44 VGND VGND VPWR VPWR sky130_fd_sc_hd__decap_3
XFILLER_14_578 VGND VGND VPWR VPWR sky130_fd_sc_hd__decap_3
XFILLER_14_589 VGND VGND VPWR VPWR sky130_fd_sc_hd__decap_3
XFILLER_41_364 VGND VGND VPWR VPWR sky130_fd_sc_hd__decap_3
XFILLER_81_55 VGND VGND VPWR VPWR sky130_fd_sc_hd__fill_1
XFILLER_81_66 VGND VGND VPWR VPWR sky130_fd_sc_hd__decap_3
XTAP_TAPCELL_ROW_52_871 VGND VPWR sky130_fd_sc_hd__tapvpwrvgnd_1
XTAP_TAPCELL_ROW_24_540 VGND VPWR sky130_fd_sc_hd__tapvpwrvgnd_1
XFILLER_14_71 VGND VGND VPWR VPWR sky130_fd_sc_hd__decap_3
XFILLER_108_672 VGND VGND VPWR VPWR sky130_fd_sc_hd__decap_3
XFILLER_115_609 VGND VGND VPWR VPWR sky130_fd_sc_hd__decap_3
XFILLER_5_254 VGND VGND VPWR VPWR sky130_fd_sc_hd__decap_3
XFILLER_5_287 VGND VGND VPWR VPWR sky130_fd_sc_hd__fill_1
XFILLER_110_303 VGND VGND VPWR VPWR sky130_fd_sc_hd__decap_3
XFILLER_1_460 VGND VGND VPWR VPWR sky130_fd_sc_hd__decap_3
XFILLER_96_515 VGND VGND VPWR VPWR sky130_fd_sc_hd__decap_3
XFILLER_1_493 VGND VGND VPWR VPWR sky130_fd_sc_hd__decap_3
XFILLER_96_548 VGND VGND VPWR VPWR sky130_fd_sc_hd__decap_3
XFILLER_37_615 VGND VGND VPWR VPWR sky130_fd_sc_hd__fill_1
XFILLER_49_464 VGND VGND VPWR VPWR sky130_fd_sc_hd__decap_3
XFILLER_36_114 VGND VGND VPWR VPWR sky130_fd_sc_hd__decap_3
XFILLER_37_626 VGND VGND VPWR VPWR sky130_fd_sc_hd__decap_3
XFILLER_37_659 VGND VGND VPWR VPWR sky130_fd_sc_hd__decap_3
XFILLER_76_272 VGND VGND VPWR VPWR sky130_fd_sc_hd__decap_3
XFILLER_24_309 VGND VGND VPWR VPWR sky130_fd_sc_hd__fill_1
XFILLER_36_136 VGND VGND VPWR VPWR sky130_fd_sc_hd__decap_3
XFILLER_52_607 VGND VGND VPWR VPWR sky130_fd_sc_hd__decap_3
XTAP_TAPCELL_ROW_108_1549 VGND VPWR sky130_fd_sc_hd__tapvpwrvgnd_1
XFILLER_51_106 VGND VGND VPWR VPWR sky130_fd_sc_hd__decap_3
X_4950_ _4950_/A _4950_/B VGND VGND VPWR VPWR _4950_/Y sky130_fd_sc_hd__nor2_2
XFILLER_60_640 VGND VGND VPWR VPWR sky130_fd_sc_hd__decap_3
X_4881_ _6998_/Q _4912_/A VGND VGND VPWR VPWR _4882_/B sky130_fd_sc_hd__or2_2
X_3901_ hold963/X _5104_/A _3900_/Y VGND VGND VPWR VPWR _7381_/D sky130_fd_sc_hd__a21bo_2
XFILLER_60_651 VGND VGND VPWR VPWR sky130_fd_sc_hd__decap_3
XFILLER_60_684 VGND VGND VPWR VPWR sky130_fd_sc_hd__decap_3
X_6620_ _6620_/A VGND VGND VPWR VPWR _6620_/Y sky130_fd_sc_hd__inv_2
X_3832_ _3728_/Y _3824_/X _3826_/X _3735_/X _3831_/X VGND VGND VPWR VPWR _3832_/X
+ sky130_fd_sc_hd__a221o_2
XFILLER_20_548 VGND VGND VPWR VPWR sky130_fd_sc_hd__decap_3
XFILLER_32_386 VGND VGND VPWR VPWR sky130_fd_sc_hd__decap_3
X_6551_ _6651_/A VGND VGND VPWR VPWR _6551_/Y sky130_fd_sc_hd__inv_2
X_3763_ hold940/X _3822_/A2 _3762_/X VGND VGND VPWR VPWR _7395_/D sky130_fd_sc_hd__a21o_2
X_6482_ _6680_/A VGND VGND VPWR VPWR _6482_/Y sky130_fd_sc_hd__inv_2
XFILLER_9_582 VGND VGND VPWR VPWR sky130_fd_sc_hd__decap_3
XFILLER_105_119 VGND VGND VPWR VPWR sky130_fd_sc_hd__decap_3
XFILLER_10_29 VGND VGND VPWR VPWR sky130_fd_sc_hd__decap_3
XFILLER_114_631 VGND VGND VPWR VPWR sky130_fd_sc_hd__decap_3
XFILLER_99_320 VGND VGND VPWR VPWR sky130_fd_sc_hd__fill_1
X_7103_ _7328_/CLK _7103_/D _6383_/Y VGND VGND VPWR VPWR _7103_/Q sky130_fd_sc_hd__dfrtp_2
X_4315_ _4315_/A _4315_/B VGND VGND VPWR VPWR _4315_/Y sky130_fd_sc_hd__nand2_2
XFILLER_99_331 VGND VGND VPWR VPWR sky130_fd_sc_hd__decap_3
XFILLER_101_303 VGND VGND VPWR VPWR sky130_fd_sc_hd__decap_3
XFILLER_114_675 VGND VGND VPWR VPWR sky130_fd_sc_hd__decap_3
XFILLER_59_228 VGND VGND VPWR VPWR sky130_fd_sc_hd__decap_3
XFILLER_87_537 VGND VGND VPWR VPWR sky130_fd_sc_hd__decap_3
XFILLER_113_196 VGND VGND VPWR VPWR sky130_fd_sc_hd__decap_3
XFILLER_19_27 VGND VGND VPWR VPWR sky130_fd_sc_hd__decap_3
X_7034_ _7349_/CLK _7034_/D _6314_/Y VGND VGND VPWR VPWR _7034_/Q sky130_fd_sc_hd__dfrtp_2
X_4246_ _7229_/Q _4349_/B1 _4348_/B1 _7133_/Q VGND VGND VPWR VPWR _4246_/X sky130_fd_sc_hd__a22o_2
XFILLER_101_358 VGND VGND VPWR VPWR sky130_fd_sc_hd__decap_3
XFILLER_28_604 VGND VGND VPWR VPWR sky130_fd_sc_hd__decap_3
XFILLER_67_250 VGND VGND VPWR VPWR sky130_fd_sc_hd__decap_3
XFILLER_74_209 VGND VGND VPWR VPWR sky130_fd_sc_hd__decap_3
XFILLER_95_570 VGND VGND VPWR VPWR sky130_fd_sc_hd__decap_3
X_4177_ _7232_/Q _4421_/A2 _4175_/X _4176_/X VGND VGND VPWR VPWR _4177_/X sky130_fd_sc_hd__a211o_2
XFILLER_28_637 VGND VGND VPWR VPWR sky130_fd_sc_hd__decap_3
XFILLER_28_648 VGND VGND VPWR VPWR sky130_fd_sc_hd__decap_3
XFILLER_82_242 VGND VGND VPWR VPWR sky130_fd_sc_hd__decap_3
XFILLER_82_253 VGND VGND VPWR VPWR sky130_fd_sc_hd__decap_3
XTAP_TAPCELL_ROW_2_279 VGND VPWR sky130_fd_sc_hd__tapvpwrvgnd_1
XFILLER_27_169 VGND VGND VPWR VPWR sky130_fd_sc_hd__decap_3
XFILLER_36_681 VGND VGND VPWR VPWR sky130_fd_sc_hd__decap_3
XFILLER_43_629 VGND VGND VPWR VPWR sky130_fd_sc_hd__decap_3
XFILLER_55_478 VGND VGND VPWR VPWR sky130_fd_sc_hd__decap_3
XFILLER_23_320 VGND VGND VPWR VPWR sky130_fd_sc_hd__fill_2
XFILLER_23_331 VGND VGND VPWR VPWR sky130_fd_sc_hd__fill_1
XFILLER_42_139 VGND VGND VPWR VPWR sky130_fd_sc_hd__fill_1
XFILLER_82_297 VGND VGND VPWR VPWR sky130_fd_sc_hd__decap_3
XFILLER_51_662 VGND VGND VPWR VPWR sky130_fd_sc_hd__decap_3
XFILLER_51_673 VGND VGND VPWR VPWR sky130_fd_sc_hd__decap_3
X_6818_ _6974_/CLK _6818_/D VGND VGND VPWR VPWR _6818_/Q sky130_fd_sc_hd__dfxtp_2
XFILLER_11_526 VGND VGND VPWR VPWR sky130_fd_sc_hd__decap_3
XFILLER_11_559 VGND VGND VPWR VPWR sky130_fd_sc_hd__fill_1
X_6749_ _6959_/CLK _6749_/D VGND VGND VPWR VPWR _6749_/Q sky130_fd_sc_hd__dfxtp_2
XTAP_TAPCELL_ROW_98_1431 VGND VPWR sky130_fd_sc_hd__tapvpwrvgnd_1
XFILLER_109_447 VGND VGND VPWR VPWR sky130_fd_sc_hd__fill_1
XFILLER_109_458 VGND VGND VPWR VPWR sky130_fd_sc_hd__decap_3
XFILLER_105_620 VGND VGND VPWR VPWR sky130_fd_sc_hd__decap_3
XFILLER_105_653 VGND VGND VPWR VPWR sky130_fd_sc_hd__decap_3
XFILLER_116_40 VGND VGND VPWR VPWR sky130_fd_sc_hd__decap_3
XFILLER_78_515 VGND VGND VPWR VPWR sky130_fd_sc_hd__decap_3
XFILLER_78_548 VGND VGND VPWR VPWR sky130_fd_sc_hd__decap_3
XFILLER_19_615 VGND VGND VPWR VPWR sky130_fd_sc_hd__fill_1
XFILLER_93_529 VGND VGND VPWR VPWR sky130_fd_sc_hd__decap_3
XFILLER_19_626 VGND VGND VPWR VPWR sky130_fd_sc_hd__decap_3
XFILLER_46_434 VGND VGND VPWR VPWR sky130_fd_sc_hd__fill_1
XFILLER_86_581 VGND VGND VPWR VPWR sky130_fd_sc_hd__decap_3
XFILLER_86_592 VGND VGND VPWR VPWR sky130_fd_sc_hd__decap_3
XTAP_TAPCELL_ROW_57_930 VGND VPWR sky130_fd_sc_hd__tapvpwrvgnd_1
XFILLER_19_659 VGND VGND VPWR VPWR sky130_fd_sc_hd__decap_3
XFILLER_34_607 VGND VGND VPWR VPWR sky130_fd_sc_hd__decap_3
XTAP_TAPCELL_ROW_57_941 VGND VPWR sky130_fd_sc_hd__tapvpwrvgnd_1
XFILLER_61_426 VGND VGND VPWR VPWR sky130_fd_sc_hd__decap_3
XFILLER_73_264 VGND VGND VPWR VPWR sky130_fd_sc_hd__fill_2
XFILLER_92_32 VGND VGND VPWR VPWR sky130_fd_sc_hd__decap_3
XFILLER_42_640 VGND VGND VPWR VPWR sky130_fd_sc_hd__decap_3
XFILLER_42_651 VGND VGND VPWR VPWR sky130_fd_sc_hd__decap_3
XFILLER_41_172 VGND VGND VPWR VPWR sky130_fd_sc_hd__fill_1
XFILLER_42_684 VGND VGND VPWR VPWR sky130_fd_sc_hd__decap_3
XFILLER_10_581 VGND VGND VPWR VPWR sky130_fd_sc_hd__decap_3
XFILLER_10_592 VGND VGND VPWR VPWR sky130_fd_sc_hd__decap_3
XFILLER_6_563 VGND VGND VPWR VPWR sky130_fd_sc_hd__decap_3
XFILLER_108_480 VGND VGND VPWR VPWR sky130_fd_sc_hd__decap_3
XFILLER_115_417 VGND VGND VPWR VPWR sky130_fd_sc_hd__decap_3
XTAP_TAPCELL_ROW_71_1103 VGND VPWR sky130_fd_sc_hd__tapvpwrvgnd_1
XFILLER_111_612 VGND VGND VPWR VPWR sky130_fd_sc_hd__decap_3
XFILLER_69_526 VGND VGND VPWR VPWR sky130_fd_sc_hd__decap_3
XFILLER_96_312 VGND VGND VPWR VPWR sky130_fd_sc_hd__fill_1
XFILLER_111_623 VGND VGND VPWR VPWR sky130_fd_sc_hd__decap_3
XFILLER_111_656 VGND VGND VPWR VPWR sky130_fd_sc_hd__decap_3
XFILLER_96_334 VGND VGND VPWR VPWR sky130_fd_sc_hd__decap_3
X_5080_ _5080_/A0 _5079_/X _5080_/S VGND VGND VPWR VPWR _7257_/D sky130_fd_sc_hd__mux2_2
X_4100_ _7269_/Q _4401_/A2 _4430_/A2 _7237_/Q _4099_/X VGND VGND VPWR VPWR _4100_/X
+ sky130_fd_sc_hd__a221o_2
XFILLER_84_507 VGND VGND VPWR VPWR sky130_fd_sc_hd__decap_3
XFILLER_110_188 VGND VGND VPWR VPWR sky130_fd_sc_hd__decap_3
XFILLER_2_85 VGND VGND VPWR VPWR sky130_fd_sc_hd__decap_3
XFILLER_37_401 VGND VGND VPWR VPWR sky130_fd_sc_hd__decap_3
XFILLER_77_570 VGND VGND VPWR VPWR sky130_fd_sc_hd__decap_3
XFILLER_64_220 VGND VGND VPWR VPWR sky130_fd_sc_hd__decap_3
XFILLER_92_551 VGND VGND VPWR VPWR sky130_fd_sc_hd__decap_3
XFILLER_18_681 VGND VGND VPWR VPWR sky130_fd_sc_hd__decap_3
XFILLER_25_629 VGND VGND VPWR VPWR sky130_fd_sc_hd__decap_3
XFILLER_37_489 VGND VGND VPWR VPWR sky130_fd_sc_hd__decap_3
XFILLER_64_253 VGND VGND VPWR VPWR sky130_fd_sc_hd__decap_3
XFILLER_64_286 VGND VGND VPWR VPWR sky130_fd_sc_hd__decap_3
XFILLER_92_584 VGND VGND VPWR VPWR sky130_fd_sc_hd__decap_3
XFILLER_92_595 VGND VGND VPWR VPWR sky130_fd_sc_hd__decap_3
XTAP_TAPCELL_ROW_69_1076 VGND VPWR sky130_fd_sc_hd__tapvpwrvgnd_1
XFILLER_17_180 VGND VGND VPWR VPWR sky130_fd_sc_hd__decap_3
XFILLER_52_448 VGND VGND VPWR VPWR sky130_fd_sc_hd__decap_3
X_4933_ _4933_/A0 _4932_/X _4979_/S VGND VGND VPWR VPWR _7266_/D sky130_fd_sc_hd__mux2_2
XTAP_TAPCELL_ROW_82_1232 VGND VPWR sky130_fd_sc_hd__tapvpwrvgnd_1
XFILLER_33_662 VGND VGND VPWR VPWR sky130_fd_sc_hd__decap_3
XFILLER_33_673 VGND VGND VPWR VPWR sky130_fd_sc_hd__decap_3
XTAP_TAPCELL_ROW_35_668 VGND VPWR sky130_fd_sc_hd__tapvpwrvgnd_1
XANTENNA_13 _5659_/B VGND VGND VPWR VPWR sky130_fd_sc_hd__diode_2
XFILLER_60_492 VGND VGND VPWR VPWR sky130_fd_sc_hd__decap_3
X_4864_ _5092_/C _4857_/X _4860_/Y _7000_/D _4997_/A1 VGND VGND VPWR VPWR _4864_/X
+ sky130_fd_sc_hd__a32o_2
X_6603_ _6603_/A VGND VGND VPWR VPWR _6603_/Y sky130_fd_sc_hd__inv_2
X_4795_ _4795_/A _4795_/B VGND VGND VPWR VPWR _4795_/X sky130_fd_sc_hd__xor2_2
X_3815_ _6928_/Q _3918_/A2 _3925_/A2 _6702_/Q VGND VGND VPWR VPWR _3815_/X sky130_fd_sc_hd__a22o_2
X_6534_ _6596_/A VGND VGND VPWR VPWR _6534_/Y sky130_fd_sc_hd__inv_2
X_3746_ _3746_/A _3746_/B _3746_/C VGND VGND VPWR VPWR _3746_/X sky130_fd_sc_hd__and3_2
X_6465_ _6625_/A VGND VGND VPWR VPWR _6465_/Y sky130_fd_sc_hd__inv_2
X_3677_ _6942_/Q VGND VGND VPWR VPWR _3677_/Y sky130_fd_sc_hd__inv_2
X_6396_ _6494_/A VGND VGND VPWR VPWR _6396_/Y sky130_fd_sc_hd__inv_2
XFILLER_102_601 VGND VGND VPWR VPWR sky130_fd_sc_hd__decap_3
XFILLER_114_472 VGND VGND VPWR VPWR sky130_fd_sc_hd__decap_3
XTAP_TAPCELL_ROW_93_1372 VGND VPWR sky130_fd_sc_hd__tapvpwrvgnd_1
XTAP_TAPCELL_ROW_7_338 VGND VPWR sky130_fd_sc_hd__tapvpwrvgnd_1
XFILLER_101_111 VGND VGND VPWR VPWR sky130_fd_sc_hd__fill_1
XFILLER_102_634 VGND VGND VPWR VPWR sky130_fd_sc_hd__decap_3
XFILLER_102_645 VGND VGND VPWR VPWR sky130_fd_sc_hd__decap_3
XFILLER_114_483 VGND VGND VPWR VPWR sky130_fd_sc_hd__decap_3
X_5278_ _5278_/A0 _5107_/X _5292_/S VGND VGND VPWR VPWR _7191_/D sky130_fd_sc_hd__mux2_2
XFILLER_102_678 VGND VGND VPWR VPWR sky130_fd_sc_hd__decap_3
XFILLER_47_209 VGND VGND VPWR VPWR sky130_fd_sc_hd__fill_2
X_7017_ _7332_/CLK _7017_/D _6297_/Y VGND VGND VPWR VPWR _7017_/Q sky130_fd_sc_hd__dfrtp_2
X_4229_ _7099_/Q _4335_/B1 _4351_/B1 _7131_/Q VGND VGND VPWR VPWR _4229_/X sky130_fd_sc_hd__a22o_2
XFILLER_68_592 VGND VGND VPWR VPWR sky130_fd_sc_hd__decap_3
XFILLER_16_607 VGND VGND VPWR VPWR sky130_fd_sc_hd__decap_3
XFILLER_46_58 VGND VGND VPWR VPWR sky130_fd_sc_hd__fill_1
XFILLER_55_220 VGND VGND VPWR VPWR sky130_fd_sc_hd__decap_3
XFILLER_102_20 VGND VGND VPWR VPWR sky130_fd_sc_hd__decap_3
XFILLER_15_117 VGND VGND VPWR VPWR sky130_fd_sc_hd__fill_2
XFILLER_55_264 VGND VGND VPWR VPWR sky130_fd_sc_hd__decap_3
XFILLER_83_573 VGND VGND VPWR VPWR sky130_fd_sc_hd__decap_3
XTAP_TAPCELL_ROW_54_900 VGND VPWR sky130_fd_sc_hd__tapvpwrvgnd_1
XFILLER_15_139 VGND VGND VPWR VPWR sky130_fd_sc_hd__decap_3
XFILLER_43_437 VGND VGND VPWR VPWR sky130_fd_sc_hd__decap_3
XFILLER_70_223 VGND VGND VPWR VPWR sky130_fd_sc_hd__decap_3
XFILLER_24_640 VGND VGND VPWR VPWR sky130_fd_sc_hd__decap_3
XFILLER_24_651 VGND VGND VPWR VPWR sky130_fd_sc_hd__decap_3
XFILLER_62_24 VGND VGND VPWR VPWR sky130_fd_sc_hd__decap_3
XFILLER_62_35 VGND VGND VPWR VPWR sky130_fd_sc_hd__decap_3
XFILLER_70_278 VGND VGND VPWR VPWR sky130_fd_sc_hd__decap_3
XFILLER_24_684 VGND VGND VPWR VPWR sky130_fd_sc_hd__decap_3
XFILLER_62_79 VGND VGND VPWR VPWR sky130_fd_sc_hd__decap_3
XFILLER_11_334 VGND VGND VPWR VPWR sky130_fd_sc_hd__fill_2
XFILLER_7_19 VGND VGND VPWR VPWR sky130_fd_sc_hd__fill_1
XFILLER_109_222 VGND VGND VPWR VPWR sky130_fd_sc_hd__fill_2
XFILLER_7_327 VGND VGND VPWR VPWR sky130_fd_sc_hd__decap_3
XFILLER_7_349 VGND VGND VPWR VPWR sky130_fd_sc_hd__fill_2
XFILLER_3_511 VGND VGND VPWR VPWR sky130_fd_sc_hd__decap_3
XFILLER_11_83 VGND VGND VPWR VPWR sky130_fd_sc_hd__decap_3
XFILLER_3_544 VGND VGND VPWR VPWR sky130_fd_sc_hd__decap_3
XFILLER_112_409 VGND VGND VPWR VPWR sky130_fd_sc_hd__decap_3
XFILLER_3_588 VGND VGND VPWR VPWR sky130_fd_sc_hd__decap_3
XFILLER_105_483 VGND VGND VPWR VPWR sky130_fd_sc_hd__decap_3
XFILLER_78_312 VGND VGND VPWR VPWR sky130_fd_sc_hd__decap_3
XFILLER_59_570 VGND VGND VPWR VPWR sky130_fd_sc_hd__decap_3
XFILLER_93_337 VGND VGND VPWR VPWR sky130_fd_sc_hd__fill_2
XFILLER_19_445 VGND VGND VPWR VPWR sky130_fd_sc_hd__decap_3
XFILLER_46_231 VGND VGND VPWR VPWR sky130_fd_sc_hd__decap_3
XFILLER_74_551 VGND VGND VPWR VPWR sky130_fd_sc_hd__decap_3
XFILLER_46_275 VGND VGND VPWR VPWR sky130_fd_sc_hd__decap_3
XFILLER_74_584 VGND VGND VPWR VPWR sky130_fd_sc_hd__decap_3
XTAP_TAPCELL_ROW_105_1508 VGND VPWR sky130_fd_sc_hd__tapvpwrvgnd_1
XFILLER_74_595 VGND VGND VPWR VPWR sky130_fd_sc_hd__decap_3
XFILLER_15_662 VGND VGND VPWR VPWR sky130_fd_sc_hd__decap_3
XFILLER_15_673 VGND VGND VPWR VPWR sky130_fd_sc_hd__decap_3
XFILLER_61_278 VGND VGND VPWR VPWR sky130_fd_sc_hd__fill_2
XFILLER_30_610 VGND VGND VPWR VPWR sky130_fd_sc_hd__decap_3
XTAP_TAPCELL_ROW_32_638 VGND VPWR sky130_fd_sc_hd__tapvpwrvgnd_1
XFILLER_30_643 VGND VGND VPWR VPWR sky130_fd_sc_hd__fill_1
XFILLER_30_654 VGND VGND VPWR VPWR sky130_fd_sc_hd__decap_3
XTAP_TAPCELL_ROW_60_969 VGND VPWR sky130_fd_sc_hd__tapvpwrvgnd_1
XFILLER_30_687 VGND VGND VPWR VPWR sky130_fd_sc_hd__decap_3
X_3600_ _3600_/A VGND VGND VPWR VPWR _3600_/Y sky130_fd_sc_hd__inv_2
XTAP_TAPCELL_ROW_12_395 VGND VPWR sky130_fd_sc_hd__tapvpwrvgnd_1
Xhold806 _6734_/Q VGND VGND VPWR VPWR _6734_/D sky130_fd_sc_hd__dlygate4sd3_1
Xhold817 _6975_/Q VGND VGND VPWR VPWR _6975_/D sky130_fd_sc_hd__dlygate4sd3_1
Xhold828 _6974_/Q VGND VGND VPWR VPWR _6974_/D sky130_fd_sc_hd__dlygate4sd3_1
XTAP_TAPCELL_ROW_116_1648 VGND VPWR sky130_fd_sc_hd__tapvpwrvgnd_1
XFILLER_115_258 VGND VGND VPWR VPWR sky130_fd_sc_hd__decap_3
Xhold839 _6806_/Q VGND VGND VPWR VPWR _6806_/D sky130_fd_sc_hd__dlygate4sd3_1
Xmax_cap558 _4294_/A VGND VGND VPWR VPWR _4612_/A sky130_fd_sc_hd__clkbuf_2
X_3462_ _7249_/Q _4599_/S _3459_/X _3461_/X VGND VGND VPWR VPWR _3462_/X sky130_fd_sc_hd__a211o_2
XTAP_TAPCELL_ROW_116_1659 VGND VPWR sky130_fd_sc_hd__tapvpwrvgnd_1
XFILLER_111_420 VGND VGND VPWR VPWR sky130_fd_sc_hd__decap_3
XFILLER_96_120 VGND VGND VPWR VPWR sky130_fd_sc_hd__decap_3
X_5132_ _5132_/A0 _5131_/X _5159_/S VGND VGND VPWR VPWR _7252_/D sky130_fd_sc_hd__mux2_2
XFILLER_97_632 VGND VGND VPWR VPWR sky130_fd_sc_hd__decap_3
XFILLER_111_464 VGND VGND VPWR VPWR sky130_fd_sc_hd__decap_3
XFILLER_96_153 VGND VGND VPWR VPWR sky130_fd_sc_hd__decap_3
XFILLER_97_676 VGND VGND VPWR VPWR sky130_fd_sc_hd__decap_3
XFILLER_97_665 VGND VGND VPWR VPWR sky130_fd_sc_hd__decap_3
XFILLER_111_497 VGND VGND VPWR VPWR sky130_fd_sc_hd__decap_3
X_5063_ hold996/X _5061_/X _5080_/S VGND VGND VPWR VPWR _7258_/D sky130_fd_sc_hd__mux2_2
XFILLER_37_253 VGND VGND VPWR VPWR sky130_fd_sc_hd__decap_3
XFILLER_65_573 VGND VGND VPWR VPWR sky130_fd_sc_hd__decap_3
XFILLER_80_554 VGND VGND VPWR VPWR sky130_fd_sc_hd__decap_3
XFILLER_80_587 VGND VGND VPWR VPWR sky130_fd_sc_hd__fill_1
XFILLER_80_598 VGND VGND VPWR VPWR sky130_fd_sc_hd__decap_3
X_4916_ _4916_/A _4916_/B VGND VGND VPWR VPWR _4967_/A sky130_fd_sc_hd__nand2_2
XFILLER_21_632 VGND VGND VPWR VPWR sky130_fd_sc_hd__decap_3
XFILLER_21_665 VGND VGND VPWR VPWR sky130_fd_sc_hd__decap_3
XFILLER_32_38 VGND VGND VPWR VPWR sky130_fd_sc_hd__decap_3
X_4847_ _4968_/A _4384_/C _4206_/X VGND VGND VPWR VPWR _4904_/B sky130_fd_sc_hd__a21oi_2
XFILLER_21_676 VGND VGND VPWR VPWR sky130_fd_sc_hd__decap_3
XFILLER_20_197 VGND VGND VPWR VPWR sky130_fd_sc_hd__decap_3
X_4778_ _4778_/A _4778_/B VGND VGND VPWR VPWR _4827_/B sky130_fd_sc_hd__and2_2
X_6517_ _6614_/A VGND VGND VPWR VPWR _6517_/Y sky130_fd_sc_hd__inv_2
X_3729_ _6968_/Q _3888_/A2 _3888_/B1 _6962_/Q VGND VGND VPWR VPWR _3729_/X sky130_fd_sc_hd__a22o_2
X_6448_ _6542_/A VGND VGND VPWR VPWR _6448_/Y sky130_fd_sc_hd__inv_2
XFILLER_106_269 VGND VGND VPWR VPWR sky130_fd_sc_hd__decap_3
XFILLER_88_610 VGND VGND VPWR VPWR sky130_fd_sc_hd__decap_3
X_6379_ _6571_/A VGND VGND VPWR VPWR _6379_/Y sky130_fd_sc_hd__inv_2
XFILLER_88_643 VGND VGND VPWR VPWR sky130_fd_sc_hd__fill_1
XFILLER_0_558 VGND VGND VPWR VPWR sky130_fd_sc_hd__fill_2
XFILLER_0_569 VGND VGND VPWR VPWR sky130_fd_sc_hd__decap_3
XFILLER_87_142 VGND VGND VPWR VPWR sky130_fd_sc_hd__decap_3
XFILLER_88_654 VGND VGND VPWR VPWR sky130_fd_sc_hd__decap_3
XFILLER_88_687 VGND VGND VPWR VPWR sky130_fd_sc_hd__decap_3
XFILLER_102_486 VGND VGND VPWR VPWR sky130_fd_sc_hd__decap_3
XFILLER_113_41 VGND VGND VPWR VPWR sky130_fd_sc_hd__decap_3
XFILLER_113_63 VGND VGND VPWR VPWR sky130_fd_sc_hd__decap_3
XFILLER_28_242 VGND VGND VPWR VPWR sky130_fd_sc_hd__fill_1
XFILLER_28_253 VGND VGND VPWR VPWR sky130_fd_sc_hd__decap_3
XFILLER_56_573 VGND VGND VPWR VPWR sky130_fd_sc_hd__decap_3
XFILLER_90_307 VGND VGND VPWR VPWR sky130_fd_sc_hd__fill_1
XFILLER_90_329 VGND VGND VPWR VPWR sky130_fd_sc_hd__decap_3
XFILLER_28_297 VGND VGND VPWR VPWR sky130_fd_sc_hd__fill_1
XFILLER_56_595 VGND VGND VPWR VPWR sky130_fd_sc_hd__decap_3
XFILLER_73_23 VGND VGND VPWR VPWR sky130_fd_sc_hd__decap_3
XFILLER_83_381 VGND VGND VPWR VPWR sky130_fd_sc_hd__decap_3
XFILLER_31_407 VGND VGND VPWR VPWR sky130_fd_sc_hd__fill_2
XFILLER_43_245 VGND VGND VPWR VPWR sky130_fd_sc_hd__decap_3
XFILLER_71_576 VGND VGND VPWR VPWR sky130_fd_sc_hd__decap_3
XFILLER_12_610 VGND VGND VPWR VPWR sky130_fd_sc_hd__decap_3
XFILLER_43_278 VGND VGND VPWR VPWR sky130_fd_sc_hd__fill_2
XFILLER_12_643 VGND VGND VPWR VPWR sky130_fd_sc_hd__fill_1
XFILLER_12_654 VGND VGND VPWR VPWR sky130_fd_sc_hd__decap_3
XTAP_TAPCELL_ROW_100_1449 VGND VPWR sky130_fd_sc_hd__tapvpwrvgnd_1
XFILLER_12_687 VGND VGND VPWR VPWR sky130_fd_sc_hd__decap_3
XFILLER_8_625 VGND VGND VPWR VPWR sky130_fd_sc_hd__decap_3
XFILLER_11_175 VGND VGND VPWR VPWR sky130_fd_sc_hd__fill_1
XFILLER_8_669 VGND VGND VPWR VPWR sky130_fd_sc_hd__decap_3
XFILLER_98_418 VGND VGND VPWR VPWR sky130_fd_sc_hd__fill_2
XFILLER_98_407 VGND VGND VPWR VPWR sky130_fd_sc_hd__decap_3
XFILLER_112_239 VGND VGND VPWR VPWR sky130_fd_sc_hd__decap_3
XFILLER_79_632 VGND VGND VPWR VPWR sky130_fd_sc_hd__decap_3
XFILLER_98_97 VGND VGND VPWR VPWR sky130_fd_sc_hd__decap_3
XFILLER_79_665 VGND VGND VPWR VPWR sky130_fd_sc_hd__decap_3
XFILLER_79_676 VGND VGND VPWR VPWR sky130_fd_sc_hd__decap_3
XTAP_TAPCELL_ROW_111_1578 VGND VPWR sky130_fd_sc_hd__tapvpwrvgnd_1
XFILLER_66_315 VGND VGND VPWR VPWR sky130_fd_sc_hd__decap_3
XFILLER_66_326 VGND VGND VPWR VPWR sky130_fd_sc_hd__decap_3
XFILLER_78_186 VGND VGND VPWR VPWR sky130_fd_sc_hd__decap_3
XFILLER_94_613 VGND VGND VPWR VPWR sky130_fd_sc_hd__decap_3
XTAP_TAPCELL_ROW_111_1589 VGND VPWR sky130_fd_sc_hd__tapvpwrvgnd_1
XFILLER_19_220 VGND VGND VPWR VPWR sky130_fd_sc_hd__decap_3
XFILLER_78_197 VGND VGND VPWR VPWR sky130_fd_sc_hd__decap_3
XFILLER_93_145 VGND VGND VPWR VPWR sky130_fd_sc_hd__decap_3
XFILLER_94_657 VGND VGND VPWR VPWR sky130_fd_sc_hd__decap_3
XFILLER_47_573 VGND VGND VPWR VPWR sky130_fd_sc_hd__decap_3
XFILLER_81_329 VGND VGND VPWR VPWR sky130_fd_sc_hd__fill_1
XFILLER_62_510 VGND VGND VPWR VPWR sky130_fd_sc_hd__fill_1
XFILLER_22_407 VGND VGND VPWR VPWR sky130_fd_sc_hd__decap_3
XFILLER_34_267 VGND VGND VPWR VPWR sky130_fd_sc_hd__decap_3
XFILLER_62_554 VGND VGND VPWR VPWR sky130_fd_sc_hd__decap_3
XTAP_TAPCELL_ROW_66_1046 VGND VPWR sky130_fd_sc_hd__tapvpwrvgnd_1
XTAP_TAPCELL_ROW_17_454 VGND VPWR sky130_fd_sc_hd__tapvpwrvgnd_1
XFILLER_15_470 VGND VGND VPWR VPWR sky130_fd_sc_hd__fill_1
XFILLER_62_587 VGND VGND VPWR VPWR sky130_fd_sc_hd__fill_1
XFILLER_62_598 VGND VGND VPWR VPWR sky130_fd_sc_hd__decap_3
XFILLER_97_3 VGND VGND VPWR VPWR sky130_fd_sc_hd__decap_3
XTAP_TAPCELL_ROW_45_796 VGND VPWR sky130_fd_sc_hd__tapvpwrvgnd_1
XFILLER_15_492 VGND VGND VPWR VPWR sky130_fd_sc_hd__fill_1
X_4701_ _6989_/Q _6990_/Q _5044_/A VGND VGND VPWR VPWR _5026_/A sky130_fd_sc_hd__and3_2
XFILLER_30_473 VGND VGND VPWR VPWR sky130_fd_sc_hd__decap_3
X_4632_ _4626_/X _4274_/Y _4631_/X VGND VGND VPWR VPWR _4916_/B sky130_fd_sc_hd__a21oi_2
X_7351_ _7351_/CLK _7351_/D _6631_/Y VGND VGND VPWR VPWR _7351_/Q sky130_fd_sc_hd__dfrtp_2
Xhold603 _6848_/Q VGND VGND VPWR VPWR _6848_/D sky130_fd_sc_hd__dlygate4sd3_1
X_4563_ _4563_/A _4563_/B VGND VGND VPWR VPWR _7299_/D sky130_fd_sc_hd__and2_2
X_7282_ _7355_/CLK _7282_/D _6562_/Y VGND VGND VPWR VPWR _7282_/Q sky130_fd_sc_hd__dfrtp_2
Xhold614 _6726_/Q VGND VGND VPWR VPWR _6726_/D sky130_fd_sc_hd__dlygate4sd3_1
Xhold625 _6858_/Q VGND VGND VPWR VPWR _6858_/D sky130_fd_sc_hd__dlygate4sd3_1
Xhold636 _6905_/Q VGND VGND VPWR VPWR _6905_/D sky130_fd_sc_hd__dlygate4sd3_1
X_6302_ _6651_/A VGND VGND VPWR VPWR _6302_/Y sky130_fd_sc_hd__inv_2
XFILLER_116_578 VGND VGND VPWR VPWR sky130_fd_sc_hd__fill_1
XFILLER_116_589 VGND VGND VPWR VPWR sky130_fd_sc_hd__decap_3
XFILLER_6_190 VGND VGND VPWR VPWR sky130_fd_sc_hd__fill_1
Xhold647 _6753_/Q VGND VGND VPWR VPWR _6753_/D sky130_fd_sc_hd__dlygate4sd3_1
Xhold658 _6839_/Q VGND VGND VPWR VPWR _6839_/D sky130_fd_sc_hd__dlygate4sd3_1
Xhold669 _6812_/Q VGND VGND VPWR VPWR _6812_/D sky130_fd_sc_hd__dlygate4sd3_1
XTAP_TAPCELL_ROW_77_1175 VGND VPWR sky130_fd_sc_hd__tapvpwrvgnd_1
XTAP_TAPCELL_ROW_90_1331 VGND VPWR sky130_fd_sc_hd__tapvpwrvgnd_1
XFILLER_69_131 VGND VGND VPWR VPWR sky130_fd_sc_hd__decap_3
X_3376_ _3376_/A _3376_/B VGND VGND VPWR VPWR _3376_/Y sky130_fd_sc_hd__nor2_2
XFILLER_111_272 VGND VGND VPWR VPWR sky130_fd_sc_hd__decap_3
XFILLER_69_175 VGND VGND VPWR VPWR sky130_fd_sc_hd__decap_3
XFILLER_85_635 VGND VGND VPWR VPWR sky130_fd_sc_hd__decap_3
X_5115_ _5101_/A _4292_/C _5113_/Y _5020_/A _5114_/Y VGND VGND VPWR VPWR _5115_/X
+ sky130_fd_sc_hd__o221a_2
XFILLER_57_337 VGND VGND VPWR VPWR sky130_fd_sc_hd__decap_3
XFILLER_84_123 VGND VGND VPWR VPWR sky130_fd_sc_hd__decap_3
XFILLER_85_668 VGND VGND VPWR VPWR sky130_fd_sc_hd__decap_3
X_5046_ _5101_/B VGND VGND VPWR VPWR _5100_/A sky130_fd_sc_hd__inv_2
XFILLER_27_49 VGND VGND VPWR VPWR sky130_fd_sc_hd__decap_3
XFILLER_38_551 VGND VGND VPWR VPWR sky130_fd_sc_hd__decap_3
XFILLER_72_318 VGND VGND VPWR VPWR sky130_fd_sc_hd__decap_3
XFILLER_85_679 VGND VGND VPWR VPWR sky130_fd_sc_hd__decap_3
XFILLER_38_584 VGND VGND VPWR VPWR sky130_fd_sc_hd__decap_3
XFILLER_38_595 VGND VGND VPWR VPWR sky130_fd_sc_hd__decap_3
XFILLER_25_234 VGND VGND VPWR VPWR sky130_fd_sc_hd__decap_3
XFILLER_53_576 VGND VGND VPWR VPWR sky130_fd_sc_hd__decap_3
XFILLER_80_351 VGND VGND VPWR VPWR sky130_fd_sc_hd__fill_1
X_6997_ _7144_/CLK _6997_/D _6277_/Y VGND VGND VPWR VPWR _6997_/Q sky130_fd_sc_hd__dfrtp_2
XFILLER_40_215 VGND VGND VPWR VPWR sky130_fd_sc_hd__decap_3
XFILLER_40_237 VGND VGND VPWR VPWR sky130_fd_sc_hd__fill_1
XFILLER_40_259 VGND VGND VPWR VPWR sky130_fd_sc_hd__decap_3
XFILLER_5_606 VGND VGND VPWR VPWR sky130_fd_sc_hd__decap_3
XFILLER_5_617 VGND VGND VPWR VPWR sky130_fd_sc_hd__decap_3
XFILLER_107_523 VGND VGND VPWR VPWR sky130_fd_sc_hd__decap_3
XFILLER_107_556 VGND VGND VPWR VPWR sky130_fd_sc_hd__decap_3
XFILLER_107_567 VGND VGND VPWR VPWR sky130_fd_sc_hd__decap_3
XFILLER_108_41 VGND VGND VPWR VPWR sky130_fd_sc_hd__decap_3
XFILLER_108_74 VGND VGND VPWR VPWR sky130_fd_sc_hd__decap_3
XFILLER_68_12 VGND VGND VPWR VPWR sky130_fd_sc_hd__decap_3
XFILLER_102_250 VGND VGND VPWR VPWR sky130_fd_sc_hd__fill_2
XFILLER_48_315 VGND VGND VPWR VPWR sky130_fd_sc_hd__fill_1
XFILLER_76_613 VGND VGND VPWR VPWR sky130_fd_sc_hd__decap_3
XFILLER_88_473 VGND VGND VPWR VPWR sky130_fd_sc_hd__decap_3
XFILLER_102_294 VGND VGND VPWR VPWR sky130_fd_sc_hd__decap_3
XFILLER_48_348 VGND VGND VPWR VPWR sky130_fd_sc_hd__decap_3
XFILLER_75_123 VGND VGND VPWR VPWR sky130_fd_sc_hd__decap_3
XFILLER_76_657 VGND VGND VPWR VPWR sky130_fd_sc_hd__decap_3
XFILLER_29_551 VGND VGND VPWR VPWR sky130_fd_sc_hd__decap_3
XFILLER_29_573 VGND VGND VPWR VPWR sky130_fd_sc_hd__decap_3
XFILLER_63_318 VGND VGND VPWR VPWR sky130_fd_sc_hd__decap_3
XFILLER_75_167 VGND VGND VPWR VPWR sky130_fd_sc_hd__fill_1
XFILLER_75_178 VGND VGND VPWR VPWR sky130_fd_sc_hd__decap_3
XFILLER_90_104 VGND VGND VPWR VPWR sky130_fd_sc_hd__decap_3
XFILLER_56_392 VGND VGND VPWR VPWR sky130_fd_sc_hd__decap_3
XFILLER_75_189 VGND VGND VPWR VPWR sky130_fd_sc_hd__decap_3
XFILLER_84_690 VGND VGND VPWR VPWR sky130_fd_sc_hd__fill_1
XFILLER_84_88 VGND VGND VPWR VPWR sky130_fd_sc_hd__fill_2
XFILLER_90_137 VGND VGND VPWR VPWR sky130_fd_sc_hd__decap_3
XFILLER_91_638 VGND VGND VPWR VPWR sky130_fd_sc_hd__decap_3
Xplace318 _5262_/S VGND VGND VPWR VPWR _5256_/S sky130_fd_sc_hd__buf_2
Xplace307 _3635_/B VGND VGND VPWR VPWR _5033_/B2 sky130_fd_sc_hd__buf_2
XFILLER_16_234 VGND VGND VPWR VPWR sky130_fd_sc_hd__decap_3
XFILLER_17_71 VGND VGND VPWR VPWR sky130_fd_sc_hd__decap_3
Xplace329 _4460_/A VGND VGND VPWR VPWR _4205_/A sky130_fd_sc_hd__buf_2
XFILLER_16_278 VGND VGND VPWR VPWR sky130_fd_sc_hd__decap_3
XFILLER_44_587 VGND VGND VPWR VPWR sky130_fd_sc_hd__fill_1
XFILLER_44_598 VGND VGND VPWR VPWR sky130_fd_sc_hd__decap_3
XFILLER_31_237 VGND VGND VPWR VPWR sky130_fd_sc_hd__fill_2
XTAP_TAPCELL_ROW_42_755 VGND VPWR sky130_fd_sc_hd__tapvpwrvgnd_1
XTAP_TAPCELL_ROW_14_424 VGND VPWR sky130_fd_sc_hd__tapvpwrvgnd_1
XFILLER_8_466 VGND VGND VPWR VPWR sky130_fd_sc_hd__decap_3
XTAP_TAPCELL_ROW_113_1607 VGND VPWR sky130_fd_sc_hd__tapvpwrvgnd_1
XFILLER_113_526 VGND VGND VPWR VPWR sky130_fd_sc_hd__decap_3
XFILLER_3_160 VGND VGND VPWR VPWR sky130_fd_sc_hd__decap_3
XFILLER_4_672 VGND VGND VPWR VPWR sky130_fd_sc_hd__decap_3
XFILLER_113_559 VGND VGND VPWR VPWR sky130_fd_sc_hd__fill_1
XFILLER_79_440 VGND VGND VPWR VPWR sky130_fd_sc_hd__decap_3
XFILLER_67_635 VGND VGND VPWR VPWR sky130_fd_sc_hd__decap_3
XFILLER_39_337 VGND VGND VPWR VPWR sky130_fd_sc_hd__fill_1
XFILLER_67_668 VGND VGND VPWR VPWR sky130_fd_sc_hd__decap_3
XFILLER_94_432 VGND VGND VPWR VPWR sky130_fd_sc_hd__decap_3
XFILLER_54_318 VGND VGND VPWR VPWR sky130_fd_sc_hd__decap_3
XFILLER_67_679 VGND VGND VPWR VPWR sky130_fd_sc_hd__decap_3
XFILLER_81_104 VGND VGND VPWR VPWR sky130_fd_sc_hd__decap_3
XFILLER_82_616 VGND VGND VPWR VPWR sky130_fd_sc_hd__decap_3
XFILLER_81_137 VGND VGND VPWR VPWR sky130_fd_sc_hd__decap_3
X_6920_ clkload8/A _6920_/D VGND VGND VPWR VPWR _6920_/Q sky130_fd_sc_hd__dfxtp_2
XFILLER_90_660 VGND VGND VPWR VPWR sky130_fd_sc_hd__decap_3
X_6851_ clkload6/A _6851_/D VGND VGND VPWR VPWR _6851_/Q sky130_fd_sc_hd__dfxtp_2
XFILLER_35_576 VGND VGND VPWR VPWR sky130_fd_sc_hd__decap_3
Xfanout19 _6667_/A VGND VGND VPWR VPWR _6663_/A sky130_fd_sc_hd__buf_2
XFILLER_22_226 VGND VGND VPWR VPWR sky130_fd_sc_hd__decap_3
XFILLER_50_557 VGND VGND VPWR VPWR sky130_fd_sc_hd__decap_3
X_6782_ _6966_/CLK _6782_/D VGND VGND VPWR VPWR _6782_/Q sky130_fd_sc_hd__dfxtp_2
X_3994_ _7345_/Q _3993_/X _3996_/S VGND VGND VPWR VPWR _7345_/D sky130_fd_sc_hd__mux2_2
X_5733_ _7372_/Q _5733_/A1 _5735_/S VGND VGND VPWR VPWR _6716_/D sky130_fd_sc_hd__mux2_2
X_5664_ _5664_/A _5664_/B _5664_/C _5664_/D VGND VGND VPWR VPWR _5665_/D sky130_fd_sc_hd__and4_2
XTAP_TAPCELL_ROW_79_1204 VGND VPWR sky130_fd_sc_hd__tapvpwrvgnd_1
X_7403_ _7403_/CLK _7403_/D _6683_/Y VGND VGND VPWR VPWR _7403_/Q sky130_fd_sc_hd__dfrtp_2
X_5595_ _5595_/A _5595_/B VGND VGND VPWR VPWR _7030_/D sky130_fd_sc_hd__or2_2
X_4615_ _4612_/A _4612_/B _3610_/A VGND VGND VPWR VPWR _4615_/Y sky130_fd_sc_hd__a21oi_2
X_7334_ _7368_/CLK _7334_/D _6614_/Y VGND VGND VPWR VPWR _7334_/Q sky130_fd_sc_hd__dfrtp_2
X_4546_ _4546_/A _4563_/B VGND VGND VPWR VPWR _7307_/D sky130_fd_sc_hd__and2_2
XFILLER_104_504 VGND VGND VPWR VPWR sky130_fd_sc_hd__decap_3
XFILLER_89_204 VGND VGND VPWR VPWR sky130_fd_sc_hd__decap_3
XFILLER_104_548 VGND VGND VPWR VPWR sky130_fd_sc_hd__decap_3
X_7265_ _7395_/CLK _7265_/D _6545_/Y VGND VGND VPWR VPWR _7265_/Q sky130_fd_sc_hd__dfrtp_2
X_7196_ _7362_/CLK _7196_/D _6476_/Y VGND VGND VPWR VPWR _7196_/Q sky130_fd_sc_hd__dfrtp_2
XFILLER_58_613 VGND VGND VPWR VPWR sky130_fd_sc_hd__decap_3
Xhold1100 _7305_/Q VGND VGND VPWR VPWR _4550_/A sky130_fd_sc_hd__dlygate4sd3_1
X_3359_ _6983_/Q _5130_/A VGND VGND VPWR VPWR _3376_/A sky130_fd_sc_hd__or2_2
XFILLER_112_581 VGND VGND VPWR VPWR sky130_fd_sc_hd__decap_3
XFILLER_112_592 VGND VGND VPWR VPWR sky130_fd_sc_hd__decap_3
XFILLER_58_657 VGND VGND VPWR VPWR sky130_fd_sc_hd__decap_3
XFILLER_85_432 VGND VGND VPWR VPWR sky130_fd_sc_hd__decap_3
XFILLER_97_281 VGND VGND VPWR VPWR sky130_fd_sc_hd__decap_3
Xhold1111 _7235_/Q VGND VGND VPWR VPWR _5186_/A sky130_fd_sc_hd__dlygate4sd3_1
Xhold1122 _7318_/Q VGND VGND VPWR VPWR _4522_/A0 sky130_fd_sc_hd__dlygate4sd3_1
Xhold1133 _7218_/Q VGND VGND VPWR VPWR _5221_/A sky130_fd_sc_hd__dlygate4sd3_1
XFILLER_57_145 VGND VGND VPWR VPWR sky130_fd_sc_hd__decap_3
Xhold1144 _7169_/Q VGND VGND VPWR VPWR _5323_/A0 sky130_fd_sc_hd__dlygate4sd3_1
Xhold1155 _7127_/Q VGND VGND VPWR VPWR _5413_/A0 sky130_fd_sc_hd__dlygate4sd3_1
Xhold1166 _7390_/Q VGND VGND VPWR VPWR _3818_/A1 sky130_fd_sc_hd__dlygate4sd3_1
XFILLER_66_690 VGND VGND VPWR VPWR sky130_fd_sc_hd__fill_1
XFILLER_72_115 VGND VGND VPWR VPWR sky130_fd_sc_hd__fill_2
XFILLER_72_126 VGND VGND VPWR VPWR sky130_fd_sc_hd__decap_3
XFILLER_72_137 VGND VGND VPWR VPWR sky130_fd_sc_hd__decap_3
XFILLER_73_638 VGND VGND VPWR VPWR sky130_fd_sc_hd__decap_3
Xhold1177 _7306_/Q VGND VGND VPWR VPWR _4548_/A sky130_fd_sc_hd__dlygate4sd3_1
Xhold1188 _7154_/Q VGND VGND VPWR VPWR _5354_/A0 sky130_fd_sc_hd__dlygate4sd3_1
Xhold1199 _7153_/Q VGND VGND VPWR VPWR _5356_/A0 sky130_fd_sc_hd__dlygate4sd3_1
XFILLER_26_565 VGND VGND VPWR VPWR sky130_fd_sc_hd__decap_3
XFILLER_53_340 VGND VGND VPWR VPWR sky130_fd_sc_hd__decap_3
XFILLER_26_598 VGND VGND VPWR VPWR sky130_fd_sc_hd__decap_3
XFILLER_81_671 VGND VGND VPWR VPWR sky130_fd_sc_hd__fill_1
XFILLER_81_682 VGND VGND VPWR VPWR sky130_fd_sc_hd__decap_3
XFILLER_110_53 VGND VGND VPWR VPWR sky130_fd_sc_hd__decap_3
XFILLER_41_557 VGND VGND VPWR VPWR sky130_fd_sc_hd__decap_3
XFILLER_80_192 VGND VGND VPWR VPWR sky130_fd_sc_hd__decap_3
XFILLER_41_579 VGND VGND VPWR VPWR sky130_fd_sc_hd__decap_3
XFILLER_110_97 VGND VGND VPWR VPWR sky130_fd_sc_hd__fill_1
XFILLER_21_281 VGND VGND VPWR VPWR sky130_fd_sc_hd__fill_1
XFILLER_21_292 VGND VGND VPWR VPWR sky130_fd_sc_hd__decap_3
XFILLER_107_364 VGND VGND VPWR VPWR sky130_fd_sc_hd__decap_3
XFILLER_1_620 VGND VGND VPWR VPWR sky130_fd_sc_hd__decap_3
XFILLER_79_77 VGND VGND VPWR VPWR sky130_fd_sc_hd__decap_3
XFILLER_110_507 VGND VGND VPWR VPWR sky130_fd_sc_hd__decap_3
XFILLER_1_653 VGND VGND VPWR VPWR sky130_fd_sc_hd__decap_3
XFILLER_0_141 VGND VGND VPWR VPWR sky130_fd_sc_hd__decap_3
XFILLER_103_570 VGND VGND VPWR VPWR sky130_fd_sc_hd__decap_3
XFILLER_95_32 VGND VGND VPWR VPWR sky130_fd_sc_hd__fill_1
XFILLER_49_635 VGND VGND VPWR VPWR sky130_fd_sc_hd__decap_3
XFILLER_88_281 VGND VGND VPWR VPWR sky130_fd_sc_hd__decap_3
XFILLER_49_668 VGND VGND VPWR VPWR sky130_fd_sc_hd__decap_3
XFILLER_49_679 VGND VGND VPWR VPWR sky130_fd_sc_hd__decap_3
XFILLER_64_616 VGND VGND VPWR VPWR sky130_fd_sc_hd__decap_3
XTAP_TAPCELL_ROW_47_814 VGND VPWR sky130_fd_sc_hd__tapvpwrvgnd_1
XFILLER_28_81 VGND VGND VPWR VPWR sky130_fd_sc_hd__decap_3
XFILLER_48_189 VGND VGND VPWR VPWR sky130_fd_sc_hd__fill_2
XFILLER_91_435 VGND VGND VPWR VPWR sky130_fd_sc_hd__decap_3
XFILLER_17_532 VGND VGND VPWR VPWR sky130_fd_sc_hd__decap_3
XFILLER_17_576 VGND VGND VPWR VPWR sky130_fd_sc_hd__decap_3
XFILLER_72_660 VGND VGND VPWR VPWR sky130_fd_sc_hd__decap_3
XTAP_TAPCELL_ROW_63_1005 VGND VPWR sky130_fd_sc_hd__tapvpwrvgnd_1
XTAP_TAPCELL_ROW_27_571 VGND VPWR sky130_fd_sc_hd__tapvpwrvgnd_1
XFILLER_44_395 VGND VGND VPWR VPWR sky130_fd_sc_hd__fill_1
XFILLER_71_192 VGND VGND VPWR VPWR sky130_fd_sc_hd__decap_3
XFILLER_32_579 VGND VGND VPWR VPWR sky130_fd_sc_hd__decap_3
XFILLER_8_230 VGND VGND VPWR VPWR sky130_fd_sc_hd__decap_3
X_4400_ _7178_/Q _4459_/C1 _4428_/B1 _7146_/Q _4399_/X VGND VGND VPWR VPWR _4400_/X
+ sky130_fd_sc_hd__a221o_2
Xoutput527 _6995_/Q VGND VGND VPWR VPWR pc_out[18] sky130_fd_sc_hd__clkdlybuf4s25_1
Xoutput516 _5362_/C VGND VGND VPWR VPWR instruction_out[8] sky130_fd_sc_hd__clkdlybuf4s25_1
Xoutput505 place204/X VGND VGND VPWR VPWR instruction_out[25] sky130_fd_sc_hd__clkdlybuf4s25_1
Xoutput549 _6986_/Q VGND VGND VPWR VPWR pc_out[9] sky130_fd_sc_hd__clkdlybuf4s25_1
Xoutput538 _7005_/Q VGND VGND VPWR VPWR pc_out[28] sky130_fd_sc_hd__clkdlybuf4s25_1
X_4331_ _7223_/Q _4331_/A2 _4534_/S _7036_/Q VGND VGND VPWR VPWR _4331_/X sky130_fd_sc_hd__a22o_2
XTAP_TAPCELL_ROW_74_1145 VGND VPWR sky130_fd_sc_hd__tapvpwrvgnd_1
XTAP_TAPCELL_ROW_74_1134 VGND VPWR sky130_fd_sc_hd__tapvpwrvgnd_1
XFILLER_99_535 VGND VGND VPWR VPWR sky130_fd_sc_hd__decap_3
XFILLER_4_480 VGND VGND VPWR VPWR sky130_fd_sc_hd__decap_3
X_7050_ _7144_/CLK _7050_/D _6330_/Y VGND VGND VPWR VPWR _7050_/Q sky130_fd_sc_hd__dfrtp_2
X_4262_ _7230_/Q _4421_/A2 _4517_/S _7294_/Q VGND VGND VPWR VPWR _4262_/X sky130_fd_sc_hd__a22o_2
XFILLER_99_579 VGND VGND VPWR VPWR sky130_fd_sc_hd__decap_3
XFILLER_101_529 VGND VGND VPWR VPWR sky130_fd_sc_hd__decap_3
XFILLER_113_378 VGND VGND VPWR VPWR sky130_fd_sc_hd__decap_3
XFILLER_79_281 VGND VGND VPWR VPWR sky130_fd_sc_hd__decap_3
X_4193_ _7359_/Q _4093_/B _4351_/A2 _7103_/Q VGND VGND VPWR VPWR _4193_/X sky130_fd_sc_hd__a22o_2
XFILLER_82_402 VGND VGND VPWR VPWR sky130_fd_sc_hd__decap_3
XFILLER_94_240 VGND VGND VPWR VPWR sky130_fd_sc_hd__decap_3
XFILLER_94_262 VGND VGND VPWR VPWR sky130_fd_sc_hd__decap_3
XFILLER_27_329 VGND VGND VPWR VPWR sky130_fd_sc_hd__decap_3
XFILLER_48_690 VGND VGND VPWR VPWR sky130_fd_sc_hd__fill_1
XFILLER_55_638 VGND VGND VPWR VPWR sky130_fd_sc_hd__decap_3
XFILLER_82_424 VGND VGND VPWR VPWR sky130_fd_sc_hd__decap_3
XFILLER_35_340 VGND VGND VPWR VPWR sky130_fd_sc_hd__decap_3
XFILLER_70_619 VGND VGND VPWR VPWR sky130_fd_sc_hd__decap_3
X_6903_ _6974_/CLK _6903_/D VGND VGND VPWR VPWR _6903_/Q sky130_fd_sc_hd__dfxtp_2
XFILLER_63_671 VGND VGND VPWR VPWR sky130_fd_sc_hd__fill_1
XFILLER_63_682 VGND VGND VPWR VPWR sky130_fd_sc_hd__decap_3
XTAP_TAPCELL_ROW_85_1274 VGND VPWR sky130_fd_sc_hd__tapvpwrvgnd_1
XFILLER_23_546 VGND VGND VPWR VPWR sky130_fd_sc_hd__decap_3
X_6834_ _6954_/CLK _6834_/D VGND VGND VPWR VPWR _6834_/Q sky130_fd_sc_hd__dfxtp_2
XFILLER_23_579 VGND VGND VPWR VPWR sky130_fd_sc_hd__decap_3
XFILLER_50_365 VGND VGND VPWR VPWR sky130_fd_sc_hd__decap_3
X_6765_ _6978_/CLK _6765_/D VGND VGND VPWR VPWR _6765_/Q sky130_fd_sc_hd__dfxtp_2
X_3977_ _7352_/Q hold977/X _3989_/S VGND VGND VPWR VPWR _7352_/D sky130_fd_sc_hd__mux2_2
XFILLER_10_218 VGND VGND VPWR VPWR sky130_fd_sc_hd__decap_3
XFILLER_109_629 VGND VGND VPWR VPWR sky130_fd_sc_hd__decap_3
X_6696_ _7378_/CLK _6696_/D VGND VGND VPWR VPWR _6696_/Q sky130_fd_sc_hd__dfxtp_2
X_5647_ _5647_/A _5647_/B VGND VGND VPWR VPWR _5647_/Y sky130_fd_sc_hd__nand2_2
XFILLER_104_301 VGND VGND VPWR VPWR sky130_fd_sc_hd__decap_3
XFILLER_104_312 VGND VGND VPWR VPWR sky130_fd_sc_hd__decap_3
XFILLER_116_172 VGND VGND VPWR VPWR sky130_fd_sc_hd__decap_3
X_7317_ _7317_/CLK _7317_/D _6597_/Y VGND VGND VPWR VPWR _7317_/Q sky130_fd_sc_hd__dfrtp_2
XFILLER_116_194 VGND VGND VPWR VPWR sky130_fd_sc_hd__fill_2
X_7248_ _7351_/CLK _7248_/D _6528_/Y VGND VGND VPWR VPWR _7248_/Q sky130_fd_sc_hd__dfrtp_2
XFILLER_105_42 VGND VGND VPWR VPWR sky130_fd_sc_hd__decap_3
XFILLER_58_421 VGND VGND VPWR VPWR sky130_fd_sc_hd__decap_3
X_7179_ _7307_/CLK _7179_/D _6459_/Y VGND VGND VPWR VPWR _7179_/Q sky130_fd_sc_hd__dfrtp_2
XFILLER_100_551 VGND VGND VPWR VPWR sky130_fd_sc_hd__decap_3
XFILLER_46_616 VGND VGND VPWR VPWR sky130_fd_sc_hd__decap_3
XFILLER_65_24 VGND VGND VPWR VPWR sky130_fd_sc_hd__decap_3
XFILLER_100_584 VGND VGND VPWR VPWR sky130_fd_sc_hd__decap_3
XFILLER_100_595 VGND VGND VPWR VPWR sky130_fd_sc_hd__decap_3
XFILLER_73_435 VGND VGND VPWR VPWR sky130_fd_sc_hd__decap_3
XFILLER_85_284 VGND VGND VPWR VPWR sky130_fd_sc_hd__decap_3
XFILLER_26_362 VGND VGND VPWR VPWR sky130_fd_sc_hd__fill_2
XFILLER_54_660 VGND VGND VPWR VPWR sky130_fd_sc_hd__decap_3
XFILLER_60_118 VGND VGND VPWR VPWR sky130_fd_sc_hd__decap_3
XFILLER_14_557 VGND VGND VPWR VPWR sky130_fd_sc_hd__decap_3
XFILLER_26_395 VGND VGND VPWR VPWR sky130_fd_sc_hd__decap_3
XFILLER_53_181 VGND VGND VPWR VPWR sky130_fd_sc_hd__decap_3
XFILLER_81_23 VGND VGND VPWR VPWR sky130_fd_sc_hd__fill_1
XFILLER_41_354 VGND VGND VPWR VPWR sky130_fd_sc_hd__decap_3
XFILLER_41_376 VGND VGND VPWR VPWR sky130_fd_sc_hd__decap_3
XTAP_TAPCELL_ROW_52_872 VGND VPWR sky130_fd_sc_hd__tapvpwrvgnd_1
XTAP_TAPCELL_ROW_24_541 VGND VPWR sky130_fd_sc_hd__tapvpwrvgnd_1
XFILLER_5_222 VGND VGND VPWR VPWR sky130_fd_sc_hd__fill_2
XFILLER_108_640 VGND VGND VPWR VPWR sky130_fd_sc_hd__decap_3
XFILLER_108_651 VGND VGND VPWR VPWR sky130_fd_sc_hd__decap_3
XFILLER_107_161 VGND VGND VPWR VPWR sky130_fd_sc_hd__decap_3
XFILLER_108_684 VGND VGND VPWR VPWR sky130_fd_sc_hd__decap_3
XFILLER_114_109 VGND VGND VPWR VPWR sky130_fd_sc_hd__decap_3
XFILLER_30_60 VGND VGND VPWR VPWR sky130_fd_sc_hd__decap_3
XFILLER_68_218 VGND VGND VPWR VPWR sky130_fd_sc_hd__decap_3
XFILLER_96_527 VGND VGND VPWR VPWR sky130_fd_sc_hd__decap_3
XFILLER_1_472 VGND VGND VPWR VPWR sky130_fd_sc_hd__decap_3
XFILLER_49_410 VGND VGND VPWR VPWR sky130_fd_sc_hd__fill_2
XFILLER_39_91 VGND VGND VPWR VPWR sky130_fd_sc_hd__decap_3
XFILLER_76_251 VGND VGND VPWR VPWR sky130_fd_sc_hd__fill_1
XFILLER_37_638 VGND VGND VPWR VPWR sky130_fd_sc_hd__decap_3
XFILLER_64_435 VGND VGND VPWR VPWR sky130_fd_sc_hd__decap_3
XFILLER_76_295 VGND VGND VPWR VPWR sky130_fd_sc_hd__decap_3
XFILLER_17_340 VGND VGND VPWR VPWR sky130_fd_sc_hd__fill_1
XFILLER_45_671 VGND VGND VPWR VPWR sky130_fd_sc_hd__fill_1
XFILLER_45_682 VGND VGND VPWR VPWR sky130_fd_sc_hd__decap_3
XFILLER_52_619 VGND VGND VPWR VPWR sky130_fd_sc_hd__decap_3
XFILLER_32_321 VGND VGND VPWR VPWR sky130_fd_sc_hd__decap_3
X_3900_ _3898_/X _3899_/X _3904_/A VGND VGND VPWR VPWR _3900_/Y sky130_fd_sc_hd__o21ai_2
XFILLER_60_663 VGND VGND VPWR VPWR sky130_fd_sc_hd__decap_3
X_3831_ _3682_/A _3828_/X _3830_/X _3714_/X VGND VGND VPWR VPWR _3831_/X sky130_fd_sc_hd__a22o_2
X_6550_ _6652_/A VGND VGND VPWR VPWR _6550_/Y sky130_fd_sc_hd__inv_2
X_3762_ _3746_/C _3759_/X _3760_/X _4832_/A VGND VGND VPWR VPWR _3762_/X sky130_fd_sc_hd__o31a_2
XFILLER_9_561 VGND VGND VPWR VPWR sky130_fd_sc_hd__decap_3
XFILLER_9_550 VGND VGND VPWR VPWR sky130_fd_sc_hd__decap_3
X_6481_ _6642_/A VGND VGND VPWR VPWR _6481_/Y sky130_fd_sc_hd__inv_2
X_3693_ _3693_/A0 _3692_/X _4832_/A VGND VGND VPWR VPWR _7403_/D sky130_fd_sc_hd__mux2_2
XFILLER_9_594 VGND VGND VPWR VPWR sky130_fd_sc_hd__decap_3
XFILLER_114_610 VGND VGND VPWR VPWR sky130_fd_sc_hd__decap_3
XFILLER_114_643 VGND VGND VPWR VPWR sky130_fd_sc_hd__fill_1
XFILLER_114_654 VGND VGND VPWR VPWR sky130_fd_sc_hd__decap_3
X_7102_ _7322_/CLK _7102_/D _6382_/Y VGND VGND VPWR VPWR _7102_/Q sky130_fd_sc_hd__dfrtp_2
X_4314_ _4376_/A _4364_/A _4364_/B _4313_/D VGND VGND VPWR VPWR _4315_/B sky130_fd_sc_hd__o31ai_2
XFILLER_114_687 VGND VGND VPWR VPWR sky130_fd_sc_hd__decap_3
XFILLER_59_207 VGND VGND VPWR VPWR sky130_fd_sc_hd__decap_3
X_5294_ _5294_/A _5294_/B VGND VGND VPWR VPWR _5294_/Y sky130_fd_sc_hd__nor2_2
XFILLER_99_376 VGND VGND VPWR VPWR sky130_fd_sc_hd__decap_3
XFILLER_101_337 VGND VGND VPWR VPWR sky130_fd_sc_hd__decap_3
XFILLER_87_549 VGND VGND VPWR VPWR sky130_fd_sc_hd__decap_3
X_7033_ _7350_/CLK _7033_/D _6313_/Y VGND VGND VPWR VPWR _7033_/Q sky130_fd_sc_hd__dfrtp_2
X_4245_ _7357_/Q _4346_/B1 _4318_/B1 _7165_/Q _4244_/X VGND VGND VPWR VPWR _4248_/B
+ sky130_fd_sc_hd__a221o_2
XFILLER_28_616 VGND VGND VPWR VPWR sky130_fd_sc_hd__decap_3
X_4176_ _7168_/Q _4318_/B1 _4420_/B1 _7136_/Q VGND VGND VPWR VPWR _4176_/X sky130_fd_sc_hd__a22o_2
XFILLER_27_104 VGND VGND VPWR VPWR sky130_fd_sc_hd__decap_3
XFILLER_55_402 VGND VGND VPWR VPWR sky130_fd_sc_hd__decap_3
XFILLER_55_424 VGND VGND VPWR VPWR sky130_fd_sc_hd__decap_3
XFILLER_67_273 VGND VGND VPWR VPWR sky130_fd_sc_hd__fill_2
XFILLER_95_582 VGND VGND VPWR VPWR sky130_fd_sc_hd__decap_3
XFILLER_55_468 VGND VGND VPWR VPWR sky130_fd_sc_hd__decap_3
XFILLER_35_38 VGND VGND VPWR VPWR sky130_fd_sc_hd__fill_2
XFILLER_36_660 VGND VGND VPWR VPWR sky130_fd_sc_hd__decap_3
XFILLER_70_405 VGND VGND VPWR VPWR sky130_fd_sc_hd__decap_3
XFILLER_82_265 VGND VGND VPWR VPWR sky130_fd_sc_hd__decap_3
XFILLER_35_181 VGND VGND VPWR VPWR sky130_fd_sc_hd__decap_3
XFILLER_51_641 VGND VGND VPWR VPWR sky130_fd_sc_hd__decap_3
X_6817_ _6970_/CLK _6817_/D VGND VGND VPWR VPWR _6817_/Q sky130_fd_sc_hd__dfxtp_2
XFILLER_11_538 VGND VGND VPWR VPWR sky130_fd_sc_hd__decap_3
XFILLER_50_173 VGND VGND VPWR VPWR sky130_fd_sc_hd__fill_1
XFILLER_51_685 VGND VGND VPWR VPWR sky130_fd_sc_hd__decap_3
XTAP_TAPCELL_ROW_21_500 VGND VPWR sky130_fd_sc_hd__tapvpwrvgnd_1
XFILLER_50_195 VGND VGND VPWR VPWR sky130_fd_sc_hd__fill_1
X_6748_ _6970_/CLK _6748_/D VGND VGND VPWR VPWR _6748_/Q sky130_fd_sc_hd__dfxtp_2
XFILLER_109_426 VGND VGND VPWR VPWR sky130_fd_sc_hd__decap_3
X_6679_ _6685_/A VGND VGND VPWR VPWR _6679_/Y sky130_fd_sc_hd__inv_2
XTAP_TAPCELL_ROW_98_1432 VGND VPWR sky130_fd_sc_hd__tapvpwrvgnd_1
XFILLER_2_203 VGND VGND VPWR VPWR sky130_fd_sc_hd__decap_3
XFILLER_104_131 VGND VGND VPWR VPWR sky130_fd_sc_hd__decap_3
XFILLER_105_632 VGND VGND VPWR VPWR sky130_fd_sc_hd__decap_3
XFILLER_105_665 VGND VGND VPWR VPWR sky130_fd_sc_hd__decap_3
XFILLER_105_676 VGND VGND VPWR VPWR sky130_fd_sc_hd__decap_3
XFILLER_104_197 VGND VGND VPWR VPWR sky130_fd_sc_hd__decap_3
XFILLER_116_63 VGND VGND VPWR VPWR sky130_fd_sc_hd__decap_3
XFILLER_116_85 VGND VGND VPWR VPWR sky130_fd_sc_hd__decap_3
XFILLER_58_251 VGND VGND VPWR VPWR sky130_fd_sc_hd__fill_1
XFILLER_86_560 VGND VGND VPWR VPWR sky130_fd_sc_hd__decap_3
XFILLER_93_508 VGND VGND VPWR VPWR sky130_fd_sc_hd__decap_3
XFILLER_18_104 VGND VGND VPWR VPWR sky130_fd_sc_hd__decap_3
XFILLER_19_638 VGND VGND VPWR VPWR sky130_fd_sc_hd__decap_3
XFILLER_58_273 VGND VGND VPWR VPWR sky130_fd_sc_hd__fill_1
XTAP_TAPCELL_ROW_29_600 VGND VPWR sky130_fd_sc_hd__tapvpwrvgnd_1
XFILLER_73_221 VGND VGND VPWR VPWR sky130_fd_sc_hd__decap_3
XFILLER_92_11 VGND VGND VPWR VPWR sky130_fd_sc_hd__decap_3
XTAP_TAPCELL_ROW_57_931 VGND VPWR sky130_fd_sc_hd__tapvpwrvgnd_1
XFILLER_27_671 VGND VGND VPWR VPWR sky130_fd_sc_hd__fill_1
XFILLER_34_619 VGND VGND VPWR VPWR sky130_fd_sc_hd__decap_3
XFILLER_73_287 VGND VGND VPWR VPWR sky130_fd_sc_hd__decap_3
XFILLER_27_682 VGND VGND VPWR VPWR sky130_fd_sc_hd__decap_3
XFILLER_61_438 VGND VGND VPWR VPWR sky130_fd_sc_hd__fill_1
XFILLER_61_449 VGND VGND VPWR VPWR sky130_fd_sc_hd__decap_3
XFILLER_14_365 VGND VGND VPWR VPWR sky130_fd_sc_hd__decap_3
XFILLER_26_192 VGND VGND VPWR VPWR sky130_fd_sc_hd__decap_3
XFILLER_42_663 VGND VGND VPWR VPWR sky130_fd_sc_hd__decap_3
XFILLER_14_398 VGND VGND VPWR VPWR sky130_fd_sc_hd__decap_3
XFILLER_10_560 VGND VGND VPWR VPWR sky130_fd_sc_hd__decap_3
XFILLER_6_531 VGND VGND VPWR VPWR sky130_fd_sc_hd__fill_1
XFILLER_6_542 VGND VGND VPWR VPWR sky130_fd_sc_hd__decap_3
XFILLER_115_429 VGND VGND VPWR VPWR sky130_fd_sc_hd__decap_3
XFILLER_6_575 VGND VGND VPWR VPWR sky130_fd_sc_hd__decap_3
XFILLER_108_492 VGND VGND VPWR VPWR sky130_fd_sc_hd__decap_3
XTAP_TAPCELL_ROW_71_1104 VGND VPWR sky130_fd_sc_hd__tapvpwrvgnd_1
XFILLER_111_635 VGND VGND VPWR VPWR sky130_fd_sc_hd__decap_3
XFILLER_111_668 VGND VGND VPWR VPWR sky130_fd_sc_hd__decap_3
XFILLER_111_679 VGND VGND VPWR VPWR sky130_fd_sc_hd__decap_3
XPHY_EDGE_ROW_10_Right_10 VGND VGND VPWR VPWR sky130_fd_sc_hd__decap_3
XFILLER_49_262 VGND VGND VPWR VPWR sky130_fd_sc_hd__fill_1
XFILLER_77_582 VGND VGND VPWR VPWR sky130_fd_sc_hd__decap_3
XFILLER_18_660 VGND VGND VPWR VPWR sky130_fd_sc_hd__decap_3
XFILLER_52_405 VGND VGND VPWR VPWR sky130_fd_sc_hd__fill_1
XFILLER_64_265 VGND VGND VPWR VPWR sky130_fd_sc_hd__decap_3
XFILLER_92_563 VGND VGND VPWR VPWR sky130_fd_sc_hd__decap_3
XTAP_TAPCELL_ROW_69_1077 VGND VPWR sky130_fd_sc_hd__tapvpwrvgnd_1
XFILLER_45_490 VGND VGND VPWR VPWR sky130_fd_sc_hd__decap_3
XFILLER_52_427 VGND VGND VPWR VPWR sky130_fd_sc_hd__decap_3
XFILLER_64_298 VGND VGND VPWR VPWR sky130_fd_sc_hd__decap_3
X_4932_ _5092_/C _4927_/X _4929_/Y _6996_/D _4997_/A1 VGND VGND VPWR VPWR _4932_/X
+ sky130_fd_sc_hd__a32o_2
XFILLER_33_641 VGND VGND VPWR VPWR sky130_fd_sc_hd__decap_3
XTAP_TAPCELL_ROW_82_1233 VGND VPWR sky130_fd_sc_hd__tapvpwrvgnd_1
XTAP_TAPCELL_ROW_35_669 VGND VPWR sky130_fd_sc_hd__tapvpwrvgnd_1
XANTENNA_14 _7004_/Q VGND VGND VPWR VPWR sky130_fd_sc_hd__diode_2
XFILLER_20_302 VGND VGND VPWR VPWR sky130_fd_sc_hd__decap_3
XFILLER_33_685 VGND VGND VPWR VPWR sky130_fd_sc_hd__decap_3
X_6602_ _6602_/A VGND VGND VPWR VPWR _6602_/Y sky130_fd_sc_hd__inv_2
XFILLER_32_184 VGND VGND VPWR VPWR sky130_fd_sc_hd__decap_3
X_3814_ _3814_/A1 _3822_/A2 _3813_/Y VGND VGND VPWR VPWR _7391_/D sky130_fd_sc_hd__a21bo_2
X_6533_ _6628_/A VGND VGND VPWR VPWR _6533_/Y sky130_fd_sc_hd__inv_2
X_3745_ _6978_/Q _3891_/A2 _3665_/X _6723_/Q _3744_/X VGND VGND VPWR VPWR _3745_/X
+ sky130_fd_sc_hd__a221o_2
XFILLER_21_29 VGND VGND VPWR VPWR sky130_fd_sc_hd__decap_3
X_6464_ _6625_/A VGND VGND VPWR VPWR _6464_/Y sky130_fd_sc_hd__inv_2
XFILLER_9_391 VGND VGND VPWR VPWR sky130_fd_sc_hd__fill_1
X_5415_ _5415_/A0 _5121_/X _5429_/S VGND VGND VPWR VPWR _7126_/D sky130_fd_sc_hd__mux2_2
X_3676_ _6716_/Q VGND VGND VPWR VPWR _3676_/Y sky130_fd_sc_hd__inv_2
X_6395_ _6494_/A VGND VGND VPWR VPWR _6395_/Y sky130_fd_sc_hd__inv_2
XFILLER_102_613 VGND VGND VPWR VPWR sky130_fd_sc_hd__decap_3
XFILLER_114_451 VGND VGND VPWR VPWR sky130_fd_sc_hd__decap_3
XFILLER_87_302 VGND VGND VPWR VPWR sky130_fd_sc_hd__decap_3
X_5346_ _5346_/A0 _5121_/X _7412_/A VGND VGND VPWR VPWR _7158_/D sky130_fd_sc_hd__mux2_2
XTAP_TAPCELL_ROW_93_1373 VGND VPWR sky130_fd_sc_hd__tapvpwrvgnd_1
XTAP_TAPCELL_ROW_93_1362 VGND VPWR sky130_fd_sc_hd__tapvpwrvgnd_1
XTAP_TAPCELL_ROW_7_339 VGND VPWR sky130_fd_sc_hd__tapvpwrvgnd_1
XFILLER_114_495 VGND VGND VPWR VPWR sky130_fd_sc_hd__decap_3
XFILLER_101_134 VGND VGND VPWR VPWR sky130_fd_sc_hd__decap_3
XFILLER_102_657 VGND VGND VPWR VPWR sky130_fd_sc_hd__decap_3
XFILLER_87_346 VGND VGND VPWR VPWR sky130_fd_sc_hd__fill_2
X_7016_ _7328_/CLK _7016_/D _6296_/Y VGND VGND VPWR VPWR _7016_/Q sky130_fd_sc_hd__dfrtp_2
X_4228_ _7014_/Q _4356_/A2 _3975_/S _7195_/Q _4227_/X VGND VGND VPWR VPWR _4228_/X
+ sky130_fd_sc_hd__a221o_2
XFILLER_101_189 VGND VGND VPWR VPWR sky130_fd_sc_hd__decap_3
XFILLER_28_424 VGND VGND VPWR VPWR sky130_fd_sc_hd__fill_2
XFILLER_68_571 VGND VGND VPWR VPWR sky130_fd_sc_hd__decap_3
XFILLER_110_690 VGND VGND VPWR VPWR sky130_fd_sc_hd__fill_1
XFILLER_28_435 VGND VGND VPWR VPWR sky130_fd_sc_hd__decap_3
XFILLER_83_541 VGND VGND VPWR VPWR sky130_fd_sc_hd__decap_3
X_4159_ _7329_/Q _3954_/S _4261_/A2 _7361_/Q _4347_/C1 VGND VGND VPWR VPWR _4159_/X
+ sky130_fd_sc_hd__a221o_2
XPHY_EDGE_ROW_106_Right_106 VGND VGND VPWR VPWR sky130_fd_sc_hd__decap_3
XFILLER_16_619 VGND VGND VPWR VPWR sky130_fd_sc_hd__decap_3
XFILLER_83_585 VGND VGND VPWR VPWR sky130_fd_sc_hd__decap_3
XTAP_TAPCELL_ROW_54_901 VGND VPWR sky130_fd_sc_hd__tapvpwrvgnd_1
XFILLER_43_449 VGND VGND VPWR VPWR sky130_fd_sc_hd__decap_3
XFILLER_55_287 VGND VGND VPWR VPWR sky130_fd_sc_hd__decap_3
XFILLER_70_235 VGND VGND VPWR VPWR sky130_fd_sc_hd__decap_3
XFILLER_102_76 VGND VGND VPWR VPWR sky130_fd_sc_hd__decap_3
XFILLER_24_663 VGND VGND VPWR VPWR sky130_fd_sc_hd__decap_3
Xclkbuf_leaf_35_clk clkload1/A VGND VGND VPWR VPWR _7311_/CLK sky130_fd_sc_hd__clkbuf_16
XFILLER_11_302 VGND VGND VPWR VPWR sky130_fd_sc_hd__fill_2
XFILLER_11_346 VGND VGND VPWR VPWR sky130_fd_sc_hd__fill_1
XFILLER_11_357 VGND VGND VPWR VPWR sky130_fd_sc_hd__decap_3
XTAP_TAPCELL_ROW_102_1480 VGND VPWR sky130_fd_sc_hd__tapvpwrvgnd_1
XFILLER_109_234 VGND VGND VPWR VPWR sky130_fd_sc_hd__fill_2
XFILLER_3_523 VGND VGND VPWR VPWR sky130_fd_sc_hd__decap_3
XFILLER_105_462 VGND VGND VPWR VPWR sky130_fd_sc_hd__decap_3
XFILLER_3_556 VGND VGND VPWR VPWR sky130_fd_sc_hd__decap_3
XFILLER_3_567 VGND VGND VPWR VPWR sky130_fd_sc_hd__decap_3
XFILLER_87_11 VGND VGND VPWR VPWR sky130_fd_sc_hd__fill_1
XFILLER_105_495 VGND VGND VPWR VPWR sky130_fd_sc_hd__decap_3
XFILLER_78_324 VGND VGND VPWR VPWR sky130_fd_sc_hd__decap_3
XFILLER_87_55 VGND VGND VPWR VPWR sky130_fd_sc_hd__fill_1
XFILLER_59_582 VGND VGND VPWR VPWR sky130_fd_sc_hd__decap_3
XFILLER_93_316 VGND VGND VPWR VPWR sky130_fd_sc_hd__decap_3
XFILLER_34_405 VGND VGND VPWR VPWR sky130_fd_sc_hd__fill_2
XFILLER_46_243 VGND VGND VPWR VPWR sky130_fd_sc_hd__decap_3
XFILLER_61_202 VGND VGND VPWR VPWR sky130_fd_sc_hd__fill_1
XFILLER_74_563 VGND VGND VPWR VPWR sky130_fd_sc_hd__decap_3
XTAP_TAPCELL_ROW_105_1509 VGND VPWR sky130_fd_sc_hd__tapvpwrvgnd_1
XFILLER_46_287 VGND VGND VPWR VPWR sky130_fd_sc_hd__decap_3
XFILLER_15_641 VGND VGND VPWR VPWR sky130_fd_sc_hd__decap_3
Xclkbuf_leaf_26_clk clkload4/A VGND VGND VPWR VPWR _7362_/CLK sky130_fd_sc_hd__clkbuf_16
XFILLER_14_162 VGND VGND VPWR VPWR sky130_fd_sc_hd__decap_3
XFILLER_15_685 VGND VGND VPWR VPWR sky130_fd_sc_hd__decap_3
XFILLER_30_622 VGND VGND VPWR VPWR sky130_fd_sc_hd__decap_3
XTAP_TAPCELL_ROW_32_639 VGND VPWR sky130_fd_sc_hd__tapvpwrvgnd_1
XFILLER_14_184 VGND VGND VPWR VPWR sky130_fd_sc_hd__decap_3
XFILLER_30_666 VGND VGND VPWR VPWR sky130_fd_sc_hd__decap_3
XTAP_TAPCELL_ROW_12_396 VGND VPWR sky130_fd_sc_hd__tapvpwrvgnd_1
XFILLER_6_361 VGND VGND VPWR VPWR sky130_fd_sc_hd__decap_3
Xhold807 _6802_/Q VGND VGND VPWR VPWR _6802_/D sky130_fd_sc_hd__dlygate4sd3_1
Xhold818 _6862_/Q VGND VGND VPWR VPWR _6862_/D sky130_fd_sc_hd__dlygate4sd3_1
XTAP_TAPCELL_ROW_116_1649 VGND VPWR sky130_fd_sc_hd__tapvpwrvgnd_1
XTAP_TAPCELL_ROW_116_1638 VGND VPWR sky130_fd_sc_hd__tapvpwrvgnd_1
Xhold829 _6915_/Q VGND VGND VPWR VPWR _6915_/D sky130_fd_sc_hd__dlygate4sd3_1
X_3461_ _7281_/Q _4532_/S _3366_/X _7153_/Q _3460_/X VGND VGND VPWR VPWR _3461_/X
+ sky130_fd_sc_hd__a221o_2
XFILLER_42_3 VGND VGND VPWR VPWR sky130_fd_sc_hd__fill_1
XFILLER_97_600 VGND VGND VPWR VPWR sky130_fd_sc_hd__decap_3
X_5200_ _5200_/A _5209_/B VGND VGND VPWR VPWR _7228_/D sky130_fd_sc_hd__and2_2
X_3392_ _3429_/A _3429_/B VGND VGND VPWR VPWR _3591_/A sky130_fd_sc_hd__nor2_2
XFILLER_69_335 VGND VGND VPWR VPWR sky130_fd_sc_hd__fill_1
X_5131_ _3992_/Y _5128_/Y _6982_/D _5156_/S VGND VGND VPWR VPWR _5131_/X sky130_fd_sc_hd__o22a_2
XFILLER_97_644 VGND VGND VPWR VPWR sky130_fd_sc_hd__decap_3
XFILLER_111_432 VGND VGND VPWR VPWR sky130_fd_sc_hd__decap_3
XFILLER_69_357 VGND VGND VPWR VPWR sky130_fd_sc_hd__decap_3
XFILLER_96_132 VGND VGND VPWR VPWR sky130_fd_sc_hd__decap_3
XFILLER_111_476 VGND VGND VPWR VPWR sky130_fd_sc_hd__decap_3
XFILLER_84_316 VGND VGND VPWR VPWR sky130_fd_sc_hd__decap_3
XFILLER_96_165 VGND VGND VPWR VPWR sky130_fd_sc_hd__decap_3
XFILLER_97_688 VGND VGND VPWR VPWR sky130_fd_sc_hd__decap_3
XFILLER_37_221 VGND VGND VPWR VPWR sky130_fd_sc_hd__decap_3
XFILLER_77_390 VGND VGND VPWR VPWR sky130_fd_sc_hd__fill_2
XFILLER_84_338 VGND VGND VPWR VPWR sky130_fd_sc_hd__decap_3
XFILLER_84_349 VGND VGND VPWR VPWR sky130_fd_sc_hd__decap_3
XFILLER_37_265 VGND VGND VPWR VPWR sky130_fd_sc_hd__decap_3
XFILLER_65_552 VGND VGND VPWR VPWR sky130_fd_sc_hd__decap_3
XFILLER_25_449 VGND VGND VPWR VPWR sky130_fd_sc_hd__decap_3
XFILLER_37_287 VGND VGND VPWR VPWR sky130_fd_sc_hd__fill_1
XFILLER_37_298 VGND VGND VPWR VPWR sky130_fd_sc_hd__decap_3
XFILLER_52_213 VGND VGND VPWR VPWR sky130_fd_sc_hd__decap_3
XFILLER_52_235 VGND VGND VPWR VPWR sky130_fd_sc_hd__decap_3
XFILLER_65_585 VGND VGND VPWR VPWR sky130_fd_sc_hd__decap_3
XFILLER_80_533 VGND VGND VPWR VPWR sky130_fd_sc_hd__decap_3
XFILLER_80_566 VGND VGND VPWR VPWR sky130_fd_sc_hd__decap_3
Xclkbuf_leaf_17_clk clkload3/A VGND VGND VPWR VPWR _7406_/CLK sky130_fd_sc_hd__clkbuf_16
XFILLER_21_600 VGND VGND VPWR VPWR sky130_fd_sc_hd__decap_3
XFILLER_21_644 VGND VGND VPWR VPWR sky130_fd_sc_hd__decap_3
X_4846_ _4903_/A _4890_/B VGND VGND VPWR VPWR _4884_/A sky130_fd_sc_hd__nand2_2
XFILLER_20_154 VGND VGND VPWR VPWR sky130_fd_sc_hd__decap_3
XFILLER_21_688 VGND VGND VPWR VPWR sky130_fd_sc_hd__decap_3
X_6516_ _6643_/A VGND VGND VPWR VPWR _6516_/Y sky130_fd_sc_hd__inv_2
X_4777_ _4927_/A _4777_/B _4777_/C VGND VGND VPWR VPWR _4777_/X sky130_fd_sc_hd__and3_2
XFILLER_4_309 VGND VGND VPWR VPWR sky130_fd_sc_hd__decap_3
X_3728_ _3746_/A _3728_/B VGND VGND VPWR VPWR _3728_/Y sky130_fd_sc_hd__nor2_2
X_6447_ _6643_/A VGND VGND VPWR VPWR _6447_/Y sky130_fd_sc_hd__inv_2
X_6378_ _6570_/A VGND VGND VPWR VPWR _6378_/Y sky130_fd_sc_hd__inv_2
XFILLER_102_421 VGND VGND VPWR VPWR sky130_fd_sc_hd__decap_3
XFILLER_114_281 VGND VGND VPWR VPWR sky130_fd_sc_hd__fill_2
XFILLER_88_622 VGND VGND VPWR VPWR sky130_fd_sc_hd__decap_3
X_5329_ _5329_/A0 _4997_/X _5340_/S VGND VGND VPWR VPWR _7166_/D sky130_fd_sc_hd__mux2_2
XFILLER_88_666 VGND VGND VPWR VPWR sky130_fd_sc_hd__decap_3
XFILLER_102_465 VGND VGND VPWR VPWR sky130_fd_sc_hd__decap_3
XFILLER_75_305 VGND VGND VPWR VPWR sky130_fd_sc_hd__fill_2
XFILLER_87_187 VGND VGND VPWR VPWR sky130_fd_sc_hd__fill_2
XFILLER_102_498 VGND VGND VPWR VPWR sky130_fd_sc_hd__decap_3
XFILLER_113_20 VGND VGND VPWR VPWR sky130_fd_sc_hd__decap_3
XFILLER_28_221 VGND VGND VPWR VPWR sky130_fd_sc_hd__decap_3
XFILLER_113_53 VGND VGND VPWR VPWR sky130_fd_sc_hd__decap_3
XFILLER_16_405 VGND VGND VPWR VPWR sky130_fd_sc_hd__decap_3
XFILLER_28_265 VGND VGND VPWR VPWR sky130_fd_sc_hd__decap_3
XFILLER_71_500 VGND VGND VPWR VPWR sky130_fd_sc_hd__decap_3
XFILLER_113_75 VGND VGND VPWR VPWR sky130_fd_sc_hd__decap_3
XFILLER_56_585 VGND VGND VPWR VPWR sky130_fd_sc_hd__decap_3
XFILLER_73_35 VGND VGND VPWR VPWR sky130_fd_sc_hd__decap_3
XFILLER_71_555 VGND VGND VPWR VPWR sky130_fd_sc_hd__decap_3
XFILLER_73_57 VGND VGND VPWR VPWR sky130_fd_sc_hd__fill_2
XFILLER_12_622 VGND VGND VPWR VPWR sky130_fd_sc_hd__decap_3
XFILLER_71_588 VGND VGND VPWR VPWR sky130_fd_sc_hd__decap_3
XFILLER_8_604 VGND VGND VPWR VPWR sky130_fd_sc_hd__decap_3
XFILLER_12_666 VGND VGND VPWR VPWR sky130_fd_sc_hd__decap_3
XFILLER_8_637 VGND VGND VPWR VPWR sky130_fd_sc_hd__decap_3
XFILLER_8_648 VGND VGND VPWR VPWR sky130_fd_sc_hd__decap_3
XFILLER_7_169 VGND VGND VPWR VPWR sky130_fd_sc_hd__decap_3
XFILLER_79_600 VGND VGND VPWR VPWR sky130_fd_sc_hd__decap_3
XFILLER_105_281 VGND VGND VPWR VPWR sky130_fd_sc_hd__decap_3
XFILLER_78_121 VGND VGND VPWR VPWR sky130_fd_sc_hd__decap_3
XFILLER_79_644 VGND VGND VPWR VPWR sky130_fd_sc_hd__decap_3
XTAP_TAPCELL_ROW_111_1579 VGND VPWR sky130_fd_sc_hd__tapvpwrvgnd_1
XFILLER_66_305 VGND VGND VPWR VPWR sky130_fd_sc_hd__decap_3
XFILLER_78_165 VGND VGND VPWR VPWR sky130_fd_sc_hd__decap_3
XFILLER_79_688 VGND VGND VPWR VPWR sky130_fd_sc_hd__decap_3
XFILLER_94_625 VGND VGND VPWR VPWR sky130_fd_sc_hd__decap_3
XFILLER_66_338 VGND VGND VPWR VPWR sky130_fd_sc_hd__fill_2
XFILLER_66_349 VGND VGND VPWR VPWR sky130_fd_sc_hd__decap_3
XFILLER_94_669 VGND VGND VPWR VPWR sky130_fd_sc_hd__decap_3
XFILLER_19_276 VGND VGND VPWR VPWR sky130_fd_sc_hd__fill_1
XFILLER_19_287 VGND VGND VPWR VPWR sky130_fd_sc_hd__decap_3
XFILLER_47_585 VGND VGND VPWR VPWR sky130_fd_sc_hd__decap_3
XFILLER_62_533 VGND VGND VPWR VPWR sky130_fd_sc_hd__decap_3
XFILLER_34_235 VGND VGND VPWR VPWR sky130_fd_sc_hd__decap_3
XFILLER_62_566 VGND VGND VPWR VPWR sky130_fd_sc_hd__decap_3
XTAP_TAPCELL_ROW_66_1047 VGND VPWR sky130_fd_sc_hd__tapvpwrvgnd_1
XTAP_TAPCELL_ROW_17_455 VGND VPWR sky130_fd_sc_hd__tapvpwrvgnd_1
XFILLER_22_419 VGND VGND VPWR VPWR sky130_fd_sc_hd__fill_1
XFILLER_34_279 VGND VGND VPWR VPWR sky130_fd_sc_hd__decap_3
XTAP_TAPCELL_ROW_45_797 VGND VPWR sky130_fd_sc_hd__tapvpwrvgnd_1
XTAP_TAPCELL_ROW_45_786 VGND VPWR sky130_fd_sc_hd__tapvpwrvgnd_1
X_5680_ _7346_/Q hold912/X _5708_/S VGND VGND VPWR VPWR _6690_/D sky130_fd_sc_hd__mux2_2
X_4700_ _6988_/Q _5066_/A VGND VGND VPWR VPWR _5044_/A sky130_fd_sc_hd__and2_2
XFILLER_30_441 VGND VGND VPWR VPWR sky130_fd_sc_hd__decap_3
X_4631_ _5003_/A _4275_/Y _4630_/X _4275_/A VGND VGND VPWR VPWR _4631_/X sky130_fd_sc_hd__a31o_2
XFILLER_8_85 VGND VGND VPWR VPWR sky130_fd_sc_hd__decap_3
XFILLER_116_502 VGND VGND VPWR VPWR sky130_fd_sc_hd__fill_2
X_7350_ _7350_/CLK _7350_/D _6630_/Y VGND VGND VPWR VPWR _7350_/Q sky130_fd_sc_hd__dfrtp_2
XFILLER_116_524 VGND VGND VPWR VPWR sky130_fd_sc_hd__decap_3
XFILLER_116_546 VGND VGND VPWR VPWR sky130_fd_sc_hd__decap_3
X_7281_ _7351_/CLK _7281_/D _6561_/Y VGND VGND VPWR VPWR _7281_/Q sky130_fd_sc_hd__dfrtp_2
Xhold604 _6825_/Q VGND VGND VPWR VPWR _6825_/D sky130_fd_sc_hd__dlygate4sd3_1
Xhold615 _6747_/Q VGND VGND VPWR VPWR _6747_/D sky130_fd_sc_hd__dlygate4sd3_1
Xhold626 _6861_/Q VGND VGND VPWR VPWR _6861_/D sky130_fd_sc_hd__dlygate4sd3_1
X_6301_ _6608_/A VGND VGND VPWR VPWR _6301_/Y sky130_fd_sc_hd__inv_2
X_4493_ _4493_/A0 _7301_/Q _4505_/S VGND VGND VPWR VPWR _7333_/D sky130_fd_sc_hd__mux2_2
Xclkbuf_leaf_6_clk clkload0/A VGND VGND VPWR VPWR _6966_/CLK sky130_fd_sc_hd__clkbuf_16
Xhold637 _6923_/Q VGND VGND VPWR VPWR _6923_/D sky130_fd_sc_hd__dlygate4sd3_1
Xhold648 _6857_/Q VGND VGND VPWR VPWR _6857_/D sky130_fd_sc_hd__dlygate4sd3_1
Xhold659 _6768_/Q VGND VGND VPWR VPWR _6768_/D sky130_fd_sc_hd__dlygate4sd3_1
XTAP_TAPCELL_ROW_77_1176 VGND VPWR sky130_fd_sc_hd__tapvpwrvgnd_1
XTAP_TAPCELL_ROW_90_1332 VGND VPWR sky130_fd_sc_hd__tapvpwrvgnd_1
X_3375_ _5118_/A _3399_/B VGND VGND VPWR VPWR _5641_/A sky130_fd_sc_hd__nand2_2
XFILLER_69_154 VGND VGND VPWR VPWR sky130_fd_sc_hd__decap_3
XFILLER_85_603 VGND VGND VPWR VPWR sky130_fd_sc_hd__decap_3
XFILLER_97_463 VGND VGND VPWR VPWR sky130_fd_sc_hd__fill_1
XFILLER_97_485 VGND VGND VPWR VPWR sky130_fd_sc_hd__decap_3
X_5114_ _5114_/A _5114_/B VGND VGND VPWR VPWR _5114_/Y sky130_fd_sc_hd__nand2_2
XFILLER_111_284 VGND VGND VPWR VPWR sky130_fd_sc_hd__decap_3
XFILLER_111_295 VGND VGND VPWR VPWR sky130_fd_sc_hd__decap_3
XFILLER_69_187 VGND VGND VPWR VPWR sky130_fd_sc_hd__decap_3
XFILLER_85_647 VGND VGND VPWR VPWR sky130_fd_sc_hd__decap_3
X_5045_ _6988_/Q _5045_/B VGND VGND VPWR VPWR _5045_/X sky130_fd_sc_hd__or2_2
XFILLER_38_563 VGND VGND VPWR VPWR sky130_fd_sc_hd__decap_3
XFILLER_65_393 VGND VGND VPWR VPWR sky130_fd_sc_hd__decap_3
XFILLER_25_257 VGND VGND VPWR VPWR sky130_fd_sc_hd__decap_3
X_6996_ _7144_/CLK _6996_/D _6276_/Y VGND VGND VPWR VPWR _6996_/Q sky130_fd_sc_hd__dfrtp_2
XFILLER_53_588 VGND VGND VPWR VPWR sky130_fd_sc_hd__decap_3
XFILLER_80_363 VGND VGND VPWR VPWR sky130_fd_sc_hd__fill_1
XFILLER_80_374 VGND VGND VPWR VPWR sky130_fd_sc_hd__decap_3
XFILLER_33_290 VGND VGND VPWR VPWR sky130_fd_sc_hd__decap_3
XFILLER_40_249 VGND VGND VPWR VPWR sky130_fd_sc_hd__decap_3
XFILLER_80_396 VGND VGND VPWR VPWR sky130_fd_sc_hd__decap_3
X_4829_ _4948_/A _4829_/B VGND VGND VPWR VPWR _4829_/Y sky130_fd_sc_hd__nor2_2
XFILLER_5_629 VGND VGND VPWR VPWR sky130_fd_sc_hd__decap_3
XFILLER_107_535 VGND VGND VPWR VPWR sky130_fd_sc_hd__decap_3
XFILLER_111_6 VGND VGND VPWR VPWR sky130_fd_sc_hd__decap_3
XFILLER_107_579 VGND VGND VPWR VPWR sky130_fd_sc_hd__decap_3
XFILLER_0_301 VGND VGND VPWR VPWR sky130_fd_sc_hd__decap_3
XFILLER_0_312 VGND VGND VPWR VPWR sky130_fd_sc_hd__decap_3
XFILLER_68_24 VGND VGND VPWR VPWR sky130_fd_sc_hd__decap_3
XFILLER_0_334 VGND VGND VPWR VPWR sky130_fd_sc_hd__fill_2
XFILLER_0_345 VGND VGND VPWR VPWR sky130_fd_sc_hd__decap_3
XFILLER_88_430 VGND VGND VPWR VPWR sky130_fd_sc_hd__decap_3
XFILLER_75_102 VGND VGND VPWR VPWR sky130_fd_sc_hd__decap_3
XFILLER_76_625 VGND VGND VPWR VPWR sky130_fd_sc_hd__decap_3
XFILLER_88_485 VGND VGND VPWR VPWR sky130_fd_sc_hd__decap_3
XFILLER_75_113 VGND VGND VPWR VPWR sky130_fd_sc_hd__fill_2
XFILLER_76_669 VGND VGND VPWR VPWR sky130_fd_sc_hd__decap_3
XFILLER_75_146 VGND VGND VPWR VPWR sky130_fd_sc_hd__decap_3
XFILLER_91_606 VGND VGND VPWR VPWR sky130_fd_sc_hd__decap_3
XFILLER_91_617 VGND VGND VPWR VPWR sky130_fd_sc_hd__decap_3
XFILLER_29_585 VGND VGND VPWR VPWR sky130_fd_sc_hd__decap_3
XFILLER_44_533 VGND VGND VPWR VPWR sky130_fd_sc_hd__decap_3
XFILLER_56_371 VGND VGND VPWR VPWR sky130_fd_sc_hd__decap_3
XFILLER_90_116 VGND VGND VPWR VPWR sky130_fd_sc_hd__decap_3
Xplace319 _5286_/S VGND VGND VPWR VPWR _5262_/S sky130_fd_sc_hd__buf_2
Xplace308 _3605_/Y VGND VGND VPWR VPWR _4811_/C sky130_fd_sc_hd__buf_2
XFILLER_44_566 VGND VGND VPWR VPWR sky130_fd_sc_hd__decap_3
XFILLER_16_268 VGND VGND VPWR VPWR sky130_fd_sc_hd__decap_3
XTAP_TAPCELL_ROW_42_756 VGND VPWR sky130_fd_sc_hd__tapvpwrvgnd_1
XTAP_TAPCELL_ROW_14_425 VGND VPWR sky130_fd_sc_hd__tapvpwrvgnd_1
XTAP_TAPCELL_ROW_14_414 VGND VPWR sky130_fd_sc_hd__tapvpwrvgnd_1
XFILLER_76_9 VGND VGND VPWR VPWR sky130_fd_sc_hd__fill_1
XFILLER_113_505 VGND VGND VPWR VPWR sky130_fd_sc_hd__decap_3
XFILLER_4_640 VGND VGND VPWR VPWR sky130_fd_sc_hd__decap_3
XFILLER_4_651 VGND VGND VPWR VPWR sky130_fd_sc_hd__decap_3
XTAP_TAPCELL_ROW_113_1608 VGND VPWR sky130_fd_sc_hd__tapvpwrvgnd_1
XFILLER_98_205 VGND VGND VPWR VPWR sky130_fd_sc_hd__decap_3
XFILLER_113_538 VGND VGND VPWR VPWR sky130_fd_sc_hd__decap_3
XFILLER_3_172 VGND VGND VPWR VPWR sky130_fd_sc_hd__fill_2
XFILLER_4_684 VGND VGND VPWR VPWR sky130_fd_sc_hd__decap_3
XFILLER_98_227 VGND VGND VPWR VPWR sky130_fd_sc_hd__fill_2
XFILLER_98_249 VGND VGND VPWR VPWR sky130_fd_sc_hd__decap_3
XFILLER_67_603 VGND VGND VPWR VPWR sky130_fd_sc_hd__decap_3
XFILLER_39_327 VGND VGND VPWR VPWR sky130_fd_sc_hd__fill_1
XFILLER_67_647 VGND VGND VPWR VPWR sky130_fd_sc_hd__decap_3
XFILLER_79_496 VGND VGND VPWR VPWR sky130_fd_sc_hd__decap_3
XFILLER_82_628 VGND VGND VPWR VPWR sky130_fd_sc_hd__decap_3
XFILLER_35_500 VGND VGND VPWR VPWR sky130_fd_sc_hd__decap_3
XFILLER_35_511 VGND VGND VPWR VPWR sky130_fd_sc_hd__decap_3
XFILLER_81_116 VGND VGND VPWR VPWR sky130_fd_sc_hd__fill_1
XFILLER_35_544 VGND VGND VPWR VPWR sky130_fd_sc_hd__fill_2
XFILLER_47_393 VGND VGND VPWR VPWR sky130_fd_sc_hd__decap_3
XFILLER_81_149 VGND VGND VPWR VPWR sky130_fd_sc_hd__decap_3
X_6850_ _6978_/CLK _6850_/D VGND VGND VPWR VPWR _6850_/Q sky130_fd_sc_hd__dfxtp_2
XFILLER_35_588 VGND VGND VPWR VPWR sky130_fd_sc_hd__decap_3
XFILLER_50_525 VGND VGND VPWR VPWR sky130_fd_sc_hd__fill_2
XFILLER_90_672 VGND VGND VPWR VPWR sky130_fd_sc_hd__decap_3
X_6781_ _7383_/CLK _6781_/D VGND VGND VPWR VPWR _6781_/Q sky130_fd_sc_hd__dfxtp_2
XPHY_EDGE_ROW_8_Right_8 VGND VGND VPWR VPWR sky130_fd_sc_hd__decap_3
X_3993_ _4467_/B _3919_/X _3991_/X _3992_/Y VGND VGND VPWR VPWR _3993_/X sky130_fd_sc_hd__a31o_2
XFILLER_15_290 VGND VGND VPWR VPWR sky130_fd_sc_hd__decap_3
XFILLER_50_569 VGND VGND VPWR VPWR sky130_fd_sc_hd__decap_3
XFILLER_30_271 VGND VGND VPWR VPWR sky130_fd_sc_hd__decap_3
X_5663_ _5663_/A _5663_/B _5663_/C _5663_/D VGND VGND VPWR VPWR _5664_/D sky130_fd_sc_hd__nor4_2
XTAP_TAPCELL_ROW_79_1205 VGND VPWR sky130_fd_sc_hd__tapvpwrvgnd_1
X_7402_ _7405_/CLK _7402_/D _6682_/Y VGND VGND VPWR VPWR _7402_/Q sky130_fd_sc_hd__dfrtp_2
X_4614_ _4614_/A _4614_/B _4614_/C _5113_/A VGND VGND VPWR VPWR _4614_/X sky130_fd_sc_hd__and4_4
X_7333_ _7365_/CLK _7333_/D _6613_/Y VGND VGND VPWR VPWR _7333_/Q sky130_fd_sc_hd__dfrtp_2
XFILLER_116_365 VGND VGND VPWR VPWR sky130_fd_sc_hd__decap_3
XFILLER_104_516 VGND VGND VPWR VPWR sky130_fd_sc_hd__decap_3
XFILLER_89_216 VGND VGND VPWR VPWR sky130_fd_sc_hd__decap_3
X_7264_ _7362_/CLK _7264_/D _6544_/Y VGND VGND VPWR VPWR _7264_/Q sky130_fd_sc_hd__dfrtp_2
X_4476_ _4476_/A0 _7309_/Q _4478_/S VGND VGND VPWR VPWR _7341_/D sky130_fd_sc_hd__mux2_2
X_7195_ _7353_/CLK _7195_/D _6475_/Y VGND VGND VPWR VPWR _7195_/Q sky130_fd_sc_hd__dfrtp_2
X_3427_ _3527_/A _3427_/B VGND VGND VPWR VPWR _3508_/A sky130_fd_sc_hd__nand2b_2
XPHY_EDGE_ROW_39_Right_39 VGND VGND VPWR VPWR sky130_fd_sc_hd__decap_3
XFILLER_112_560 VGND VGND VPWR VPWR sky130_fd_sc_hd__decap_3
XFILLER_58_625 VGND VGND VPWR VPWR sky130_fd_sc_hd__decap_3
XFILLER_85_411 VGND VGND VPWR VPWR sky130_fd_sc_hd__decap_3
X_3358_ _3469_/A _3469_/B _3449_/A _3365_/A VGND VGND VPWR VPWR _4599_/S sky130_fd_sc_hd__o211a_4
XFILLER_38_49 VGND VGND VPWR VPWR sky130_fd_sc_hd__decap_3
XFILLER_57_124 VGND VGND VPWR VPWR sky130_fd_sc_hd__fill_1
XFILLER_85_444 VGND VGND VPWR VPWR sky130_fd_sc_hd__fill_1
Xhold1101 _7238_/Q VGND VGND VPWR VPWR _5179_/A sky130_fd_sc_hd__dlygate4sd3_1
Xhold1112 _7231_/Q VGND VGND VPWR VPWR _5194_/A sky130_fd_sc_hd__dlygate4sd3_1
Xhold1123 _7286_/Q VGND VGND VPWR VPWR _4589_/A sky130_fd_sc_hd__dlygate4sd3_1
XFILLER_58_669 VGND VGND VPWR VPWR sky130_fd_sc_hd__decap_3
XFILLER_73_606 VGND VGND VPWR VPWR sky130_fd_sc_hd__decap_3
XFILLER_73_617 VGND VGND VPWR VPWR sky130_fd_sc_hd__decap_3
Xhold1134 _7405_/Q VGND VGND VPWR VPWR _3671_/A1 sky130_fd_sc_hd__dlygate4sd3_1
Xhold1145 _7321_/Q VGND VGND VPWR VPWR _4517_/A0 sky130_fd_sc_hd__dlygate4sd3_1
Xhold1156 _7164_/Q VGND VGND VPWR VPWR _5333_/A0 sky130_fd_sc_hd__dlygate4sd3_1
Xhold1167 _7282_/Q VGND VGND VPWR VPWR _4530_/A1 sky130_fd_sc_hd__dlygate4sd3_1
XFILLER_38_360 VGND VGND VPWR VPWR sky130_fd_sc_hd__decap_3
XFILLER_38_371 VGND VGND VPWR VPWR sky130_fd_sc_hd__fill_2
XFILLER_85_488 VGND VGND VPWR VPWR sky130_fd_sc_hd__fill_2
Xhold1178 _7341_/Q VGND VGND VPWR VPWR _4476_/A0 sky130_fd_sc_hd__dlygate4sd3_1
Xhold1189 _7146_/Q VGND VGND VPWR VPWR _5373_/A0 sky130_fd_sc_hd__dlygate4sd3_1
X_5028_ _5028_/A0 _5027_/X _5080_/S VGND VGND VPWR VPWR _7260_/D sky130_fd_sc_hd__mux2_2
XFILLER_26_533 VGND VGND VPWR VPWR sky130_fd_sc_hd__fill_2
XFILLER_81_650 VGND VGND VPWR VPWR sky130_fd_sc_hd__decap_3
XFILLER_13_205 VGND VGND VPWR VPWR sky130_fd_sc_hd__decap_3
XFILLER_26_577 VGND VGND VPWR VPWR sky130_fd_sc_hd__decap_3
XFILLER_110_21 VGND VGND VPWR VPWR sky130_fd_sc_hd__decap_3
XFILLER_110_32 VGND VGND VPWR VPWR sky130_fd_sc_hd__decap_3
XFILLER_13_238 VGND VGND VPWR VPWR sky130_fd_sc_hd__decap_3
XFILLER_13_249 VGND VGND VPWR VPWR sky130_fd_sc_hd__decap_3
X_6979_ clkload7/A _6979_/D _6259_/Y VGND VGND VPWR VPWR _6979_/Q sky130_fd_sc_hd__dfrtp_2
XPHY_EDGE_ROW_48_Right_48 VGND VGND VPWR VPWR sky130_fd_sc_hd__decap_3
XFILLER_110_65 VGND VGND VPWR VPWR sky130_fd_sc_hd__decap_3
XFILLER_107_343 VGND VGND VPWR VPWR sky130_fd_sc_hd__decap_3
XFILLER_1_610 VGND VGND VPWR VPWR sky130_fd_sc_hd__decap_3
XPHY_EDGE_ROW_57_Right_57 VGND VGND VPWR VPWR sky130_fd_sc_hd__decap_3
XFILLER_1_632 VGND VGND VPWR VPWR sky130_fd_sc_hd__decap_3
XFILLER_79_89 VGND VGND VPWR VPWR sky130_fd_sc_hd__decap_3
Xhold990 _7382_/Q VGND VGND VPWR VPWR hold990/X sky130_fd_sc_hd__dlygate4sd3_1
XFILLER_110_519 VGND VGND VPWR VPWR sky130_fd_sc_hd__decap_3
XFILLER_1_665 VGND VGND VPWR VPWR sky130_fd_sc_hd__decap_3
XFILLER_1_676 VGND VGND VPWR VPWR sky130_fd_sc_hd__decap_3
XFILLER_49_603 VGND VGND VPWR VPWR sky130_fd_sc_hd__decap_3
XFILLER_95_11 VGND VGND VPWR VPWR sky130_fd_sc_hd__decap_3
XFILLER_95_208 VGND VGND VPWR VPWR sky130_fd_sc_hd__decap_3
XFILLER_0_197 VGND VGND VPWR VPWR sky130_fd_sc_hd__decap_3
XFILLER_103_582 VGND VGND VPWR VPWR sky130_fd_sc_hd__decap_3
XFILLER_49_647 VGND VGND VPWR VPWR sky130_fd_sc_hd__decap_3
XFILLER_76_444 VGND VGND VPWR VPWR sky130_fd_sc_hd__fill_2
XFILLER_48_168 VGND VGND VPWR VPWR sky130_fd_sc_hd__decap_3
XFILLER_95_99 VGND VGND VPWR VPWR sky130_fd_sc_hd__decap_3
XFILLER_28_60 VGND VGND VPWR VPWR sky130_fd_sc_hd__fill_1
XFILLER_36_319 VGND VGND VPWR VPWR sky130_fd_sc_hd__decap_3
XFILLER_64_628 VGND VGND VPWR VPWR sky130_fd_sc_hd__decap_3
XTAP_TAPCELL_ROW_47_815 VGND VPWR sky130_fd_sc_hd__tapvpwrvgnd_1
XFILLER_17_544 VGND VGND VPWR VPWR sky130_fd_sc_hd__decap_3
XFILLER_17_588 VGND VGND VPWR VPWR sky130_fd_sc_hd__decap_3
XFILLER_44_352 VGND VGND VPWR VPWR sky130_fd_sc_hd__decap_3
XFILLER_71_160 VGND VGND VPWR VPWR sky130_fd_sc_hd__decap_3
XFILLER_72_672 VGND VGND VPWR VPWR sky130_fd_sc_hd__decap_3
XTAP_TAPCELL_ROW_63_1006 VGND VPWR sky130_fd_sc_hd__tapvpwrvgnd_1
XPHY_EDGE_ROW_66_Right_66 VGND VGND VPWR VPWR sky130_fd_sc_hd__decap_3
XFILLER_32_536 VGND VGND VPWR VPWR sky130_fd_sc_hd__fill_1
XFILLER_32_558 VGND VGND VPWR VPWR sky130_fd_sc_hd__decap_3
XTAP_TAPCELL_ROW_27_572 VGND VPWR sky130_fd_sc_hd__tapvpwrvgnd_1
XFILLER_8_220 VGND VGND VPWR VPWR sky130_fd_sc_hd__fill_1
XFILLER_8_242 VGND VGND VPWR VPWR sky130_fd_sc_hd__decap_3
XFILLER_8_253 VGND VGND VPWR VPWR sky130_fd_sc_hd__decap_3
XFILLER_8_264 VGND VGND VPWR VPWR sky130_fd_sc_hd__decap_3
XFILLER_8_286 VGND VGND VPWR VPWR sky130_fd_sc_hd__decap_3
Xoutput517 _5646_/Y VGND VGND VPWR VPWR instruction_out[9] sky130_fd_sc_hd__clkdlybuf4s25_1
Xoutput506 _5649_/X VGND VGND VPWR VPWR instruction_out[26] sky130_fd_sc_hd__clkdlybuf4s25_1
XPHY_EDGE_ROW_75_Right_75 VGND VGND VPWR VPWR sky130_fd_sc_hd__decap_3
Xoutput539 _7006_/Q VGND VGND VPWR VPWR pc_out[29] sky130_fd_sc_hd__clkdlybuf4s25_1
Xoutput528 _6996_/Q VGND VGND VPWR VPWR pc_out[19] sky130_fd_sc_hd__clkdlybuf4s25_1
X_4330_ _5057_/B _4330_/B VGND VGND VPWR VPWR _4619_/B sky130_fd_sc_hd__or2_2
XTAP_TAPCELL_ROW_74_1135 VGND VPWR sky130_fd_sc_hd__tapvpwrvgnd_1
XFILLER_99_514 VGND VGND VPWR VPWR sky130_fd_sc_hd__decap_3
XFILLER_113_346 VGND VGND VPWR VPWR sky130_fd_sc_hd__fill_1
XFILLER_113_357 VGND VGND VPWR VPWR sky130_fd_sc_hd__decap_3
XFILLER_4_492 VGND VGND VPWR VPWR sky130_fd_sc_hd__decap_3
XFILLER_5_86 VGND VGND VPWR VPWR sky130_fd_sc_hd__decap_3
X_4261_ _7358_/Q _4261_/A2 _4348_/A2 _7166_/Q _4347_/C1 VGND VGND VPWR VPWR _4261_/X
+ sky130_fd_sc_hd__a221o_2
XFILLER_99_547 VGND VGND VPWR VPWR sky130_fd_sc_hd__decap_3
XFILLER_101_508 VGND VGND VPWR VPWR sky130_fd_sc_hd__decap_3
XFILLER_79_293 VGND VGND VPWR VPWR sky130_fd_sc_hd__decap_3
X_4192_ _4637_/B _4637_/C VGND VGND VPWR VPWR _4380_/A sky130_fd_sc_hd__and2_2
XFILLER_27_308 VGND VGND VPWR VPWR sky130_fd_sc_hd__decap_3
XFILLER_55_606 VGND VGND VPWR VPWR sky130_fd_sc_hd__decap_3
XFILLER_55_617 VGND VGND VPWR VPWR sky130_fd_sc_hd__decap_3
XFILLER_54_105 VGND VGND VPWR VPWR sky130_fd_sc_hd__fill_1
XFILLER_82_436 VGND VGND VPWR VPWR sky130_fd_sc_hd__decap_3
XPHY_EDGE_ROW_84_Right_84 VGND VGND VPWR VPWR sky130_fd_sc_hd__decap_3
XPHY_EDGE_ROW_19_Left_136 VGND VGND VPWR VPWR sky130_fd_sc_hd__decap_3
XFILLER_35_330 VGND VGND VPWR VPWR sky130_fd_sc_hd__decap_3
XFILLER_54_149 VGND VGND VPWR VPWR sky130_fd_sc_hd__decap_3
XFILLER_63_650 VGND VGND VPWR VPWR sky130_fd_sc_hd__decap_3
X_6902_ _6968_/CLK _6902_/D VGND VGND VPWR VPWR _6902_/Q sky130_fd_sc_hd__dfxtp_2
XFILLER_35_352 VGND VGND VPWR VPWR sky130_fd_sc_hd__decap_3
XFILLER_50_300 VGND VGND VPWR VPWR sky130_fd_sc_hd__decap_3
XFILLER_62_160 VGND VGND VPWR VPWR sky130_fd_sc_hd__fill_1
X_6833_ clkload9/A _6833_/D VGND VGND VPWR VPWR _6833_/Q sky130_fd_sc_hd__dfxtp_2
XTAP_TAPCELL_ROW_85_1275 VGND VPWR sky130_fd_sc_hd__tapvpwrvgnd_1
XFILLER_90_480 VGND VGND VPWR VPWR sky130_fd_sc_hd__fill_1
XFILLER_23_558 VGND VGND VPWR VPWR sky130_fd_sc_hd__fill_2
X_6764_ _6959_/CLK _6764_/D VGND VGND VPWR VPWR _6764_/Q sky130_fd_sc_hd__dfxtp_2
X_6695_ _7378_/CLK _6695_/D VGND VGND VPWR VPWR _6695_/Q sky130_fd_sc_hd__dfxtp_2
X_5715_ _7363_/Q hold909/X _5735_/S VGND VGND VPWR VPWR _6707_/D sky130_fd_sc_hd__mux2_2
XFILLER_31_591 VGND VGND VPWR VPWR sky130_fd_sc_hd__decap_3
X_5646_ _5646_/A VGND VGND VPWR VPWR _5646_/Y sky130_fd_sc_hd__inv_2
XPHY_EDGE_ROW_28_Left_145 VGND VGND VPWR VPWR sky130_fd_sc_hd__decap_3
XFILLER_108_129 VGND VGND VPWR VPWR sky130_fd_sc_hd__decap_3
XPHY_EDGE_ROW_93_Right_93 VGND VGND VPWR VPWR sky130_fd_sc_hd__decap_3
X_5577_ _5577_/A0 _5038_/X _5593_/B VGND VGND VPWR VPWR _7040_/D sky130_fd_sc_hd__mux2_2
XFILLER_2_418 VGND VGND VPWR VPWR sky130_fd_sc_hd__fill_2
X_7316_ _7349_/CLK _7316_/D _6596_/Y VGND VGND VPWR VPWR _7316_/Q sky130_fd_sc_hd__dfrtp_2
X_4528_ _4528_/A _4528_/B VGND VGND VPWR VPWR _7315_/D sky130_fd_sc_hd__or2_2
XFILLER_104_324 VGND VGND VPWR VPWR sky130_fd_sc_hd__decap_3
XFILLER_6_9 VGND VGND VPWR VPWR sky130_fd_sc_hd__decap_3
X_7247_ _7349_/CLK _7247_/D _6527_/Y VGND VGND VPWR VPWR _7247_/Q sky130_fd_sc_hd__dfrtp_2
X_4459_ _4040_/Y _4457_/X _4458_/X _4459_/C1 VGND VGND VPWR VPWR _5655_/B sky130_fd_sc_hd__o211a_2
XFILLER_104_368 VGND VGND VPWR VPWR sky130_fd_sc_hd__decap_3
XFILLER_77_219 VGND VGND VPWR VPWR sky130_fd_sc_hd__decap_3
XFILLER_105_21 VGND VGND VPWR VPWR sky130_fd_sc_hd__decap_3
XFILLER_58_411 VGND VGND VPWR VPWR sky130_fd_sc_hd__decap_3
X_7178_ _7406_/CLK _7178_/D _6458_/Y VGND VGND VPWR VPWR _7178_/Q sky130_fd_sc_hd__dfrtp_2
XFILLER_100_563 VGND VGND VPWR VPWR sky130_fd_sc_hd__decap_3
XFILLER_105_54 VGND VGND VPWR VPWR sky130_fd_sc_hd__fill_2
XFILLER_58_444 VGND VGND VPWR VPWR sky130_fd_sc_hd__decap_3
XFILLER_85_252 VGND VGND VPWR VPWR sky130_fd_sc_hd__decap_3
XPHY_EDGE_ROW_37_Left_154 VGND VGND VPWR VPWR sky130_fd_sc_hd__decap_3
XFILLER_46_628 VGND VGND VPWR VPWR sky130_fd_sc_hd__decap_3
XFILLER_58_477 VGND VGND VPWR VPWR sky130_fd_sc_hd__decap_3
XFILLER_65_47 VGND VGND VPWR VPWR sky130_fd_sc_hd__fill_1
XFILLER_61_609 VGND VGND VPWR VPWR sky130_fd_sc_hd__decap_3
XFILLER_65_69 VGND VGND VPWR VPWR sky130_fd_sc_hd__decap_3
XFILLER_54_672 VGND VGND VPWR VPWR sky130_fd_sc_hd__decap_3
XFILLER_14_536 VGND VGND VPWR VPWR sky130_fd_sc_hd__decap_3
XFILLER_53_160 VGND VGND VPWR VPWR sky130_fd_sc_hd__decap_3
XFILLER_53_193 VGND VGND VPWR VPWR sky130_fd_sc_hd__decap_3
XFILLER_14_569 VGND VGND VPWR VPWR sky130_fd_sc_hd__decap_3
XTAP_TAPCELL_ROW_24_542 VGND VPWR sky130_fd_sc_hd__tapvpwrvgnd_1
XFILLER_22_580 VGND VGND VPWR VPWR sky130_fd_sc_hd__decap_3
XTAP_TAPCELL_ROW_52_873 VGND VPWR sky130_fd_sc_hd__tapvpwrvgnd_1
XPHY_EDGE_ROW_46_Left_163 VGND VGND VPWR VPWR sky130_fd_sc_hd__decap_3
XFILLER_108_663 VGND VGND VPWR VPWR sky130_fd_sc_hd__decap_3
XFILLER_5_234 VGND VGND VPWR VPWR sky130_fd_sc_hd__fill_1
XFILLER_5_245 VGND VGND VPWR VPWR sky130_fd_sc_hd__decap_3
XFILLER_107_140 VGND VGND VPWR VPWR sky130_fd_sc_hd__decap_3
XFILLER_5_267 VGND VGND VPWR VPWR sky130_fd_sc_hd__decap_3
XFILLER_107_195 VGND VGND VPWR VPWR sky130_fd_sc_hd__decap_3
XFILLER_49_400 VGND VGND VPWR VPWR sky130_fd_sc_hd__fill_2
XFILLER_96_506 VGND VGND VPWR VPWR sky130_fd_sc_hd__decap_3
XPHY_EDGE_ROW_55_Left_172 VGND VGND VPWR VPWR sky130_fd_sc_hd__decap_3
XFILLER_1_484 VGND VGND VPWR VPWR sky130_fd_sc_hd__decap_3
XFILLER_89_591 VGND VGND VPWR VPWR sky130_fd_sc_hd__decap_3
XFILLER_96_539 VGND VGND VPWR VPWR sky130_fd_sc_hd__decap_3
XFILLER_37_606 VGND VGND VPWR VPWR sky130_fd_sc_hd__decap_3
XFILLER_49_455 VGND VGND VPWR VPWR sky130_fd_sc_hd__decap_3
XFILLER_37_617 VGND VGND VPWR VPWR sky130_fd_sc_hd__decap_3
XFILLER_64_403 VGND VGND VPWR VPWR sky130_fd_sc_hd__decap_3
XFILLER_17_352 VGND VGND VPWR VPWR sky130_fd_sc_hd__decap_3
XFILLER_45_650 VGND VGND VPWR VPWR sky130_fd_sc_hd__decap_3
XFILLER_17_396 VGND VGND VPWR VPWR sky130_fd_sc_hd__decap_3
XFILLER_44_171 VGND VGND VPWR VPWR sky130_fd_sc_hd__decap_3
XFILLER_60_631 VGND VGND VPWR VPWR sky130_fd_sc_hd__decap_3
XFILLER_72_480 VGND VGND VPWR VPWR sky130_fd_sc_hd__decap_3
XFILLER_32_333 VGND VGND VPWR VPWR sky130_fd_sc_hd__decap_3
XFILLER_32_355 VGND VGND VPWR VPWR sky130_fd_sc_hd__decap_3
XFILLER_60_675 VGND VGND VPWR VPWR sky130_fd_sc_hd__decap_3
X_3830_ _6860_/Q _3903_/A2 _3903_/B1 _6852_/Q _3829_/X VGND VGND VPWR VPWR _3830_/X
+ sky130_fd_sc_hd__a221o_2
XPHY_EDGE_ROW_64_Left_181 VGND VGND VPWR VPWR sky130_fd_sc_hd__decap_3
XFILLER_20_528 VGND VGND VPWR VPWR sky130_fd_sc_hd__decap_3
XFILLER_20_539 VGND VGND VPWR VPWR sky130_fd_sc_hd__decap_3
XFILLER_13_591 VGND VGND VPWR VPWR sky130_fd_sc_hd__decap_3
XFILLER_72_3 VGND VGND VPWR VPWR sky130_fd_sc_hd__decap_3
X_6480_ _6637_/A VGND VGND VPWR VPWR _6480_/Y sky130_fd_sc_hd__inv_2
X_3692_ _6715_/Q _3917_/A2 _3902_/B1 _6893_/Q _3691_/X VGND VGND VPWR VPWR _3692_/X
+ sky130_fd_sc_hd__a221o_2
XFILLER_9_573 VGND VGND VPWR VPWR sky130_fd_sc_hd__decap_3
XFILLER_114_622 VGND VGND VPWR VPWR sky130_fd_sc_hd__decap_3
X_5362_ _3378_/A _5646_/A _5362_/C VGND VGND VPWR VPWR _5425_/S sky130_fd_sc_hd__and3b_2
X_7101_ _7322_/CLK _7101_/D _6381_/Y VGND VGND VPWR VPWR _7101_/Q sky130_fd_sc_hd__dfrtp_2
X_4313_ _4376_/A _4364_/A _4364_/B _4313_/D VGND VGND VPWR VPWR _4315_/A sky130_fd_sc_hd__or4_4
XPHY_EDGE_ROW_73_Left_190 VGND VGND VPWR VPWR sky130_fd_sc_hd__decap_3
XFILLER_114_666 VGND VGND VPWR VPWR sky130_fd_sc_hd__decap_3
XFILLER_59_219 VGND VGND VPWR VPWR sky130_fd_sc_hd__decap_3
XFILLER_87_528 VGND VGND VPWR VPWR sky130_fd_sc_hd__decap_3
X_7032_ _7350_/CLK _7032_/D _6312_/Y VGND VGND VPWR VPWR _7032_/Q sky130_fd_sc_hd__dfrtp_2
XFILLER_101_316 VGND VGND VPWR VPWR sky130_fd_sc_hd__decap_3
X_4244_ _7293_/Q _4517_/S VGND VGND VPWR VPWR _4244_/X sky130_fd_sc_hd__and2_2
XFILLER_101_349 VGND VGND VPWR VPWR sky130_fd_sc_hd__decap_3
XFILLER_67_241 VGND VGND VPWR VPWR sky130_fd_sc_hd__fill_1
XFILLER_95_550 VGND VGND VPWR VPWR sky130_fd_sc_hd__decap_3
XFILLER_95_561 VGND VGND VPWR VPWR sky130_fd_sc_hd__decap_3
X_4175_ _7328_/Q _3964_/S _4347_/C1 _4174_/X VGND VGND VPWR VPWR _4175_/X sky130_fd_sc_hd__a211o_2
XFILLER_28_628 VGND VGND VPWR VPWR sky130_fd_sc_hd__decap_3
XFILLER_82_211 VGND VGND VPWR VPWR sky130_fd_sc_hd__decap_3
XFILLER_95_594 VGND VGND VPWR VPWR sky130_fd_sc_hd__decap_3
XFILLER_27_149 VGND VGND VPWR VPWR sky130_fd_sc_hd__decap_3
XFILLER_55_458 VGND VGND VPWR VPWR sky130_fd_sc_hd__fill_2
XFILLER_67_296 VGND VGND VPWR VPWR sky130_fd_sc_hd__decap_3
XFILLER_82_233 VGND VGND VPWR VPWR sky130_fd_sc_hd__decap_3
XFILLER_36_672 VGND VGND VPWR VPWR sky130_fd_sc_hd__decap_3
XFILLER_43_609 VGND VGND VPWR VPWR sky130_fd_sc_hd__decap_3
XFILLER_23_311 VGND VGND VPWR VPWR sky130_fd_sc_hd__decap_3
XFILLER_51_620 VGND VGND VPWR VPWR sky130_fd_sc_hd__decap_3
XFILLER_51_653 VGND VGND VPWR VPWR sky130_fd_sc_hd__decap_3
X_6816_ _6954_/CLK _6816_/D VGND VGND VPWR VPWR _6816_/Q sky130_fd_sc_hd__dfxtp_2
XFILLER_23_377 VGND VGND VPWR VPWR sky130_fd_sc_hd__decap_3
X_6747_ clkload6/A _6747_/D VGND VGND VPWR VPWR _6747_/Q sky130_fd_sc_hd__dfxtp_2
XTAP_TAPCELL_ROW_21_501 VGND VPWR sky130_fd_sc_hd__tapvpwrvgnd_1
XTAP_TAPCELL_ROW_98_1422 VGND VPWR sky130_fd_sc_hd__tapvpwrvgnd_1
XFILLER_109_438 VGND VGND VPWR VPWR sky130_fd_sc_hd__decap_3
X_6678_ _6678_/A VGND VGND VPWR VPWR _6678_/Y sky130_fd_sc_hd__inv_2
XTAP_TAPCELL_ROW_98_1433 VGND VPWR sky130_fd_sc_hd__tapvpwrvgnd_1
XFILLER_109_449 VGND VGND VPWR VPWR sky130_fd_sc_hd__decap_3
XFILLER_105_600 VGND VGND VPWR VPWR sky130_fd_sc_hd__decap_3
XFILLER_105_644 VGND VGND VPWR VPWR sky130_fd_sc_hd__decap_3
XFILLER_105_688 VGND VGND VPWR VPWR sky130_fd_sc_hd__decap_3
XFILLER_2_248 VGND VGND VPWR VPWR sky130_fd_sc_hd__decap_3
XFILLER_78_528 VGND VGND VPWR VPWR sky130_fd_sc_hd__decap_3
XFILLER_78_539 VGND VGND VPWR VPWR sky130_fd_sc_hd__decap_3
XFILLER_19_606 VGND VGND VPWR VPWR sky130_fd_sc_hd__decap_3
XFILLER_100_360 VGND VGND VPWR VPWR sky130_fd_sc_hd__fill_1
XFILLER_19_617 VGND VGND VPWR VPWR sky130_fd_sc_hd__decap_3
XFILLER_46_403 VGND VGND VPWR VPWR sky130_fd_sc_hd__decap_3
XFILLER_46_425 VGND VGND VPWR VPWR sky130_fd_sc_hd__decap_3
XFILLER_76_79 VGND VGND VPWR VPWR sky130_fd_sc_hd__decap_3
XFILLER_86_572 VGND VGND VPWR VPWR sky130_fd_sc_hd__decap_3
XTAP_TAPCELL_ROW_29_601 VGND VPWR sky130_fd_sc_hd__tapvpwrvgnd_1
XFILLER_73_233 VGND VGND VPWR VPWR sky130_fd_sc_hd__decap_3
XTAP_TAPCELL_ROW_57_932 VGND VPWR sky130_fd_sc_hd__tapvpwrvgnd_1
XFILLER_27_650 VGND VGND VPWR VPWR sky130_fd_sc_hd__decap_3
XFILLER_46_469 VGND VGND VPWR VPWR sky130_fd_sc_hd__decap_3
XFILLER_73_255 VGND VGND VPWR VPWR sky130_fd_sc_hd__decap_3
XFILLER_73_277 VGND VGND VPWR VPWR sky130_fd_sc_hd__decap_3
XFILLER_92_23 VGND VGND VPWR VPWR sky130_fd_sc_hd__decap_3
XTAP_TAPCELL_ROW_107_1540 VGND VPWR sky130_fd_sc_hd__tapvpwrvgnd_1
XFILLER_14_322 VGND VGND VPWR VPWR sky130_fd_sc_hd__fill_1
XFILLER_42_631 VGND VGND VPWR VPWR sky130_fd_sc_hd__decap_3
XFILLER_73_299 VGND VGND VPWR VPWR sky130_fd_sc_hd__decap_3
XFILLER_25_94 VGND VGND VPWR VPWR sky130_fd_sc_hd__decap_3
XFILLER_42_675 VGND VGND VPWR VPWR sky130_fd_sc_hd__decap_3
XFILLER_10_572 VGND VGND VPWR VPWR sky130_fd_sc_hd__decap_3
XFILLER_6_510 VGND VGND VPWR VPWR sky130_fd_sc_hd__decap_3
XFILLER_6_554 VGND VGND VPWR VPWR sky130_fd_sc_hd__decap_3
XFILLER_108_460 VGND VGND VPWR VPWR sky130_fd_sc_hd__decap_3
XFILLER_115_408 VGND VGND VPWR VPWR sky130_fd_sc_hd__decap_3
XFILLER_6_587 VGND VGND VPWR VPWR sky130_fd_sc_hd__fill_1
XFILLER_6_598 VGND VGND VPWR VPWR sky130_fd_sc_hd__decap_3
XFILLER_111_603 VGND VGND VPWR VPWR sky130_fd_sc_hd__decap_3
XFILLER_69_517 VGND VGND VPWR VPWR sky130_fd_sc_hd__fill_1
XTAP_TAPCELL_ROW_71_1105 VGND VPWR sky130_fd_sc_hd__tapvpwrvgnd_1
XFILLER_111_647 VGND VGND VPWR VPWR sky130_fd_sc_hd__decap_3
XFILLER_96_325 VGND VGND VPWR VPWR sky130_fd_sc_hd__decap_3
XFILLER_1_281 VGND VGND VPWR VPWR sky130_fd_sc_hd__decap_3
XFILLER_2_32 VGND VGND VPWR VPWR sky130_fd_sc_hd__fill_2
XFILLER_77_561 VGND VGND VPWR VPWR sky130_fd_sc_hd__decap_3
XFILLER_37_425 VGND VGND VPWR VPWR sky130_fd_sc_hd__fill_2
XFILLER_77_594 VGND VGND VPWR VPWR sky130_fd_sc_hd__decap_3
XFILLER_92_520 VGND VGND VPWR VPWR sky130_fd_sc_hd__decap_3
XFILLER_92_542 VGND VGND VPWR VPWR sky130_fd_sc_hd__decap_3
XFILLER_18_672 VGND VGND VPWR VPWR sky130_fd_sc_hd__decap_3
XFILLER_24_108 VGND VGND VPWR VPWR sky130_fd_sc_hd__fill_2
XFILLER_25_609 VGND VGND VPWR VPWR sky130_fd_sc_hd__decap_3
XFILLER_37_469 VGND VGND VPWR VPWR sky130_fd_sc_hd__fill_2
XFILLER_64_277 VGND VGND VPWR VPWR sky130_fd_sc_hd__decap_3
XFILLER_92_575 VGND VGND VPWR VPWR sky130_fd_sc_hd__decap_3
XTAP_TAPCELL_ROW_69_1078 VGND VPWR sky130_fd_sc_hd__tapvpwrvgnd_1
XFILLER_24_119 VGND VGND VPWR VPWR sky130_fd_sc_hd__decap_3
XFILLER_33_620 VGND VGND VPWR VPWR sky130_fd_sc_hd__decap_3
XFILLER_52_439 VGND VGND VPWR VPWR sky130_fd_sc_hd__decap_3
X_4931_ _4931_/A _4931_/B VGND VGND VPWR VPWR _6996_/D sky130_fd_sc_hd__nor2_2
XFILLER_33_653 VGND VGND VPWR VPWR sky130_fd_sc_hd__decap_3
X_4862_ _4825_/B _4862_/B VGND VGND VPWR VPWR _7000_/D sky130_fd_sc_hd__and2b_2
XTAP_TAPCELL_ROW_82_1234 VGND VPWR sky130_fd_sc_hd__tapvpwrvgnd_1
X_6601_ _6640_/A VGND VGND VPWR VPWR _6601_/Y sky130_fd_sc_hd__inv_2
X_3813_ _3802_/X _3812_/X _3991_/A VGND VGND VPWR VPWR _3813_/Y sky130_fd_sc_hd__o21ai_2
XANTENNA_15 _6984_/Q VGND VGND VPWR VPWR sky130_fd_sc_hd__diode_2
XFILLER_20_325 VGND VGND VPWR VPWR sky130_fd_sc_hd__decap_3
X_4793_ _4793_/A0 _4792_/X _4837_/S VGND VGND VPWR VPWR _7274_/D sky130_fd_sc_hd__mux2_2
X_6532_ _6628_/A VGND VGND VPWR VPWR _6532_/Y sky130_fd_sc_hd__inv_2
X_3744_ _6728_/Q _3892_/A2 _3878_/A2 _6973_/Q VGND VGND VPWR VPWR _3744_/X sky130_fd_sc_hd__a22o_2
X_6463_ _6662_/A VGND VGND VPWR VPWR _6463_/Y sky130_fd_sc_hd__inv_2
XFILLER_114_430 VGND VGND VPWR VPWR sky130_fd_sc_hd__decap_3
X_6394_ _6586_/A VGND VGND VPWR VPWR _6394_/Y sky130_fd_sc_hd__inv_2
XFILLER_114_463 VGND VGND VPWR VPWR sky130_fd_sc_hd__decap_3
XTAP_TAPCELL_ROW_93_1363 VGND VPWR sky130_fd_sc_hd__tapvpwrvgnd_1
XFILLER_102_625 VGND VGND VPWR VPWR sky130_fd_sc_hd__decap_3
XFILLER_87_314 VGND VGND VPWR VPWR sky130_fd_sc_hd__fill_1
X_5276_ _5276_/A0 _5094_/X _5286_/S VGND VGND VPWR VPWR _7192_/D sky130_fd_sc_hd__mux2_2
XFILLER_99_185 VGND VGND VPWR VPWR sky130_fd_sc_hd__decap_3
XFILLER_101_146 VGND VGND VPWR VPWR sky130_fd_sc_hd__decap_3
XFILLER_102_669 VGND VGND VPWR VPWR sky130_fd_sc_hd__decap_3
XFILLER_87_369 VGND VGND VPWR VPWR sky130_fd_sc_hd__decap_3
X_7015_ _7344_/CLK _7015_/D _6295_/Y VGND VGND VPWR VPWR _7015_/Q sky130_fd_sc_hd__dfrtp_2
X_4227_ _7355_/Q _4337_/B _4352_/B1 _7163_/Q VGND VGND VPWR VPWR _4227_/X sky130_fd_sc_hd__a22o_2
XFILLER_68_583 VGND VGND VPWR VPWR sky130_fd_sc_hd__decap_3
XFILLER_55_211 VGND VGND VPWR VPWR sky130_fd_sc_hd__decap_3
XFILLER_95_391 VGND VGND VPWR VPWR sky130_fd_sc_hd__fill_1
X_4158_ _4158_/A _4158_/B VGND VGND VPWR VPWR _4920_/A sky130_fd_sc_hd__nand2_2
XFILLER_102_11 VGND VGND VPWR VPWR sky130_fd_sc_hd__decap_3
XFILLER_55_255 VGND VGND VPWR VPWR sky130_fd_sc_hd__decap_3
XFILLER_83_553 VGND VGND VPWR VPWR sky130_fd_sc_hd__decap_3
XFILLER_83_564 VGND VGND VPWR VPWR sky130_fd_sc_hd__decap_3
X_4089_ _7206_/Q _3958_/S _4419_/B1 _7398_/Q VGND VGND VPWR VPWR _4089_/X sky130_fd_sc_hd__a22o_2
XTAP_TAPCELL_ROW_54_902 VGND VPWR sky130_fd_sc_hd__tapvpwrvgnd_1
XFILLER_36_480 VGND VGND VPWR VPWR sky130_fd_sc_hd__fill_1
XFILLER_70_203 VGND VGND VPWR VPWR sky130_fd_sc_hd__decap_3
XFILLER_70_214 VGND VGND VPWR VPWR sky130_fd_sc_hd__decap_3
XFILLER_83_597 VGND VGND VPWR VPWR sky130_fd_sc_hd__decap_3
XFILLER_24_631 VGND VGND VPWR VPWR sky130_fd_sc_hd__decap_3
XFILLER_62_15 VGND VGND VPWR VPWR sky130_fd_sc_hd__decap_3
XFILLER_70_247 VGND VGND VPWR VPWR sky130_fd_sc_hd__decap_3
XFILLER_70_269 VGND VGND VPWR VPWR sky130_fd_sc_hd__decap_3
XFILLER_11_314 VGND VGND VPWR VPWR sky130_fd_sc_hd__fill_2
XFILLER_24_675 VGND VGND VPWR VPWR sky130_fd_sc_hd__decap_3
XFILLER_51_472 VGND VGND VPWR VPWR sky130_fd_sc_hd__decap_3
XFILLER_11_325 VGND VGND VPWR VPWR sky130_fd_sc_hd__decap_3
XTAP_TAPCELL_ROW_62_990 VGND VPWR sky130_fd_sc_hd__tapvpwrvgnd_1
XTAP_TAPCELL_ROW_102_1481 VGND VPWR sky130_fd_sc_hd__tapvpwrvgnd_1
XTAP_TAPCELL_ROW_102_1470 VGND VPWR sky130_fd_sc_hd__tapvpwrvgnd_1
XFILLER_109_213 VGND VGND VPWR VPWR sky130_fd_sc_hd__decap_3
XFILLER_11_369 VGND VGND VPWR VPWR sky130_fd_sc_hd__decap_3
XFILLER_7_318 VGND VGND VPWR VPWR sky130_fd_sc_hd__decap_3
XFILLER_109_257 VGND VGND VPWR VPWR sky130_fd_sc_hd__decap_3
XFILLER_3_502 VGND VGND VPWR VPWR sky130_fd_sc_hd__fill_2
XFILLER_3_535 VGND VGND VPWR VPWR sky130_fd_sc_hd__decap_3
XFILLER_2_3 VGND VGND VPWR VPWR sky130_fd_sc_hd__decap_3
XFILLER_3_579 VGND VGND VPWR VPWR sky130_fd_sc_hd__decap_3
XFILLER_105_474 VGND VGND VPWR VPWR sky130_fd_sc_hd__decap_3
XFILLER_78_303 VGND VGND VPWR VPWR sky130_fd_sc_hd__decap_3
XFILLER_78_336 VGND VGND VPWR VPWR sky130_fd_sc_hd__decap_3
XFILLER_66_509 VGND VGND VPWR VPWR sky130_fd_sc_hd__fill_2
XFILLER_59_561 VGND VGND VPWR VPWR sky130_fd_sc_hd__decap_3
XFILLER_19_425 VGND VGND VPWR VPWR sky130_fd_sc_hd__fill_1
XFILLER_19_436 VGND VGND VPWR VPWR sky130_fd_sc_hd__decap_3
XFILLER_46_211 VGND VGND VPWR VPWR sky130_fd_sc_hd__decap_3
XFILLER_59_594 VGND VGND VPWR VPWR sky130_fd_sc_hd__decap_3
XFILLER_74_542 VGND VGND VPWR VPWR sky130_fd_sc_hd__decap_3
XFILLER_19_458 VGND VGND VPWR VPWR sky130_fd_sc_hd__fill_1
XFILLER_74_575 VGND VGND VPWR VPWR sky130_fd_sc_hd__decap_3
XFILLER_15_620 VGND VGND VPWR VPWR sky130_fd_sc_hd__decap_3
XFILLER_36_82 VGND VGND VPWR VPWR sky130_fd_sc_hd__fill_2
XFILLER_61_225 VGND VGND VPWR VPWR sky130_fd_sc_hd__fill_1
XFILLER_15_653 VGND VGND VPWR VPWR sky130_fd_sc_hd__decap_3
XFILLER_61_236 VGND VGND VPWR VPWR sky130_fd_sc_hd__decap_3
XFILLER_61_269 VGND VGND VPWR VPWR sky130_fd_sc_hd__decap_3
XFILLER_14_141 VGND VGND VPWR VPWR sky130_fd_sc_hd__decap_3
XFILLER_30_601 VGND VGND VPWR VPWR sky130_fd_sc_hd__decap_3
XFILLER_42_461 VGND VGND VPWR VPWR sky130_fd_sc_hd__fill_2
XFILLER_14_174 VGND VGND VPWR VPWR sky130_fd_sc_hd__decap_3
XFILLER_30_634 VGND VGND VPWR VPWR sky130_fd_sc_hd__decap_3
XFILLER_30_645 VGND VGND VPWR VPWR sky130_fd_sc_hd__decap_3
XFILLER_30_678 VGND VGND VPWR VPWR sky130_fd_sc_hd__decap_3
Xhold808 _6889_/Q VGND VGND VPWR VPWR _6889_/D sky130_fd_sc_hd__dlygate4sd3_1
Xhold819 _6804_/Q VGND VGND VPWR VPWR _6804_/D sky130_fd_sc_hd__dlygate4sd3_1
XTAP_TAPCELL_ROW_12_397 VGND VPWR sky130_fd_sc_hd__tapvpwrvgnd_1
XTAP_TAPCELL_ROW_116_1639 VGND VPWR sky130_fd_sc_hd__tapvpwrvgnd_1
XFILLER_115_216 VGND VGND VPWR VPWR sky130_fd_sc_hd__fill_1
X_3460_ _7313_/Q _3996_/S _4338_/B1 _7345_/Q _3556_/A VGND VGND VPWR VPWR _3460_/X
+ sky130_fd_sc_hd__a221o_2
X_3391_ _7251_/Q _4599_/S _3390_/X VGND VGND VPWR VPWR _3589_/A sky130_fd_sc_hd__a21oi_2
XFILLER_111_411 VGND VGND VPWR VPWR sky130_fd_sc_hd__decap_3
XFILLER_69_303 VGND VGND VPWR VPWR sky130_fd_sc_hd__fill_2
XFILLER_96_111 VGND VGND VPWR VPWR sky130_fd_sc_hd__decap_3
X_5130_ _5130_/A _5670_/B _5130_/C VGND VGND VPWR VPWR _6982_/D sky130_fd_sc_hd__nor3_2
XFILLER_97_623 VGND VGND VPWR VPWR sky130_fd_sc_hd__decap_3
XFILLER_97_612 VGND VGND VPWR VPWR sky130_fd_sc_hd__decap_3
XFILLER_111_444 VGND VGND VPWR VPWR sky130_fd_sc_hd__decap_3
XFILLER_111_455 VGND VGND VPWR VPWR sky130_fd_sc_hd__decap_3
XFILLER_69_369 VGND VGND VPWR VPWR sky130_fd_sc_hd__decap_3
XFILLER_96_144 VGND VGND VPWR VPWR sky130_fd_sc_hd__decap_3
X_5061_ _6988_/D _5060_/X _5156_/S VGND VGND VPWR VPWR _5061_/X sky130_fd_sc_hd__mux2_2
XFILLER_97_656 VGND VGND VPWR VPWR sky130_fd_sc_hd__decap_3
XFILLER_111_488 VGND VGND VPWR VPWR sky130_fd_sc_hd__decap_3
XFILLER_84_306 VGND VGND VPWR VPWR sky130_fd_sc_hd__fill_2
XFILLER_96_177 VGND VGND VPWR VPWR sky130_fd_sc_hd__decap_3
XFILLER_37_244 VGND VGND VPWR VPWR sky130_fd_sc_hd__fill_2
XFILLER_65_564 VGND VGND VPWR VPWR sky130_fd_sc_hd__decap_3
XFILLER_92_361 VGND VGND VPWR VPWR sky130_fd_sc_hd__decap_3
XFILLER_52_203 VGND VGND VPWR VPWR sky130_fd_sc_hd__decap_3
XFILLER_52_225 VGND VGND VPWR VPWR sky130_fd_sc_hd__decap_3
XFILLER_65_597 VGND VGND VPWR VPWR sky130_fd_sc_hd__decap_3
XFILLER_92_394 VGND VGND VPWR VPWR sky130_fd_sc_hd__decap_3
XFILLER_52_247 VGND VGND VPWR VPWR sky130_fd_sc_hd__decap_3
XFILLER_80_545 VGND VGND VPWR VPWR sky130_fd_sc_hd__decap_3
X_4914_ _4914_/A0 _4913_/X _4946_/S VGND VGND VPWR VPWR _7267_/D sky130_fd_sc_hd__mux2_2
XFILLER_21_612 VGND VGND VPWR VPWR sky130_fd_sc_hd__decap_3
XFILLER_80_578 VGND VGND VPWR VPWR sky130_fd_sc_hd__decap_3
XFILLER_80_589 VGND VGND VPWR VPWR sky130_fd_sc_hd__decap_3
XFILLER_21_623 VGND VGND VPWR VPWR sky130_fd_sc_hd__decap_3
XFILLER_21_656 VGND VGND VPWR VPWR sky130_fd_sc_hd__decap_3
XFILLER_60_291 VGND VGND VPWR VPWR sky130_fd_sc_hd__decap_3
X_4845_ _4845_/A VGND VGND VPWR VPWR _4872_/A sky130_fd_sc_hd__inv_2
XFILLER_20_144 VGND VGND VPWR VPWR sky130_fd_sc_hd__fill_2
XFILLER_20_166 VGND VGND VPWR VPWR sky130_fd_sc_hd__decap_3
X_4776_ _7004_/Q _4804_/A VGND VGND VPWR VPWR _4777_/C sky130_fd_sc_hd__or2_2
X_6515_ _6614_/A VGND VGND VPWR VPWR _6515_/Y sky130_fd_sc_hd__inv_2
X_3727_ _3746_/B _3733_/C VGND VGND VPWR VPWR _3728_/B sky130_fd_sc_hd__nand2_2
X_6446_ _6542_/A VGND VGND VPWR VPWR _6446_/Y sky130_fd_sc_hd__inv_2
XFILLER_88_601 VGND VGND VPWR VPWR sky130_fd_sc_hd__decap_3
X_6377_ _6608_/A VGND VGND VPWR VPWR _6377_/Y sky130_fd_sc_hd__inv_2
X_3589_ _3589_/A _3589_/B VGND VGND VPWR VPWR _3590_/B sky130_fd_sc_hd__nor2_2
XFILLER_0_505 VGND VGND VPWR VPWR sky130_fd_sc_hd__decap_3
XFILLER_0_527 VGND VGND VPWR VPWR sky130_fd_sc_hd__decap_3
XFILLER_102_411 VGND VGND VPWR VPWR sky130_fd_sc_hd__fill_1
XFILLER_88_634 VGND VGND VPWR VPWR sky130_fd_sc_hd__decap_3
XFILLER_0_549 VGND VGND VPWR VPWR sky130_fd_sc_hd__decap_3
XFILLER_87_133 VGND VGND VPWR VPWR sky130_fd_sc_hd__decap_3
XFILLER_88_645 VGND VGND VPWR VPWR sky130_fd_sc_hd__decap_3
XFILLER_88_678 VGND VGND VPWR VPWR sky130_fd_sc_hd__decap_3
XFILLER_102_477 VGND VGND VPWR VPWR sky130_fd_sc_hd__decap_3
XFILLER_28_200 VGND VGND VPWR VPWR sky130_fd_sc_hd__fill_2
XFILLER_113_32 VGND VGND VPWR VPWR sky130_fd_sc_hd__decap_3
XFILLER_28_233 VGND VGND VPWR VPWR sky130_fd_sc_hd__decap_3
XFILLER_56_542 VGND VGND VPWR VPWR sky130_fd_sc_hd__decap_3
XFILLER_56_564 VGND VGND VPWR VPWR sky130_fd_sc_hd__decap_3
XFILLER_113_87 VGND VGND VPWR VPWR sky130_fd_sc_hd__decap_3
XFILLER_43_225 VGND VGND VPWR VPWR sky130_fd_sc_hd__decap_3
XFILLER_73_14 VGND VGND VPWR VPWR sky130_fd_sc_hd__fill_1
XFILLER_43_236 VGND VGND VPWR VPWR sky130_fd_sc_hd__decap_3
XFILLER_71_567 VGND VGND VPWR VPWR sky130_fd_sc_hd__decap_3
XFILLER_12_601 VGND VGND VPWR VPWR sky130_fd_sc_hd__decap_3
XFILLER_43_269 VGND VGND VPWR VPWR sky130_fd_sc_hd__decap_3
XFILLER_12_634 VGND VGND VPWR VPWR sky130_fd_sc_hd__decap_3
XFILLER_12_645 VGND VGND VPWR VPWR sky130_fd_sc_hd__decap_3
XFILLER_12_678 VGND VGND VPWR VPWR sky130_fd_sc_hd__decap_3
XFILLER_8_616 VGND VGND VPWR VPWR sky130_fd_sc_hd__decap_3
XFILLER_11_166 VGND VGND VPWR VPWR sky130_fd_sc_hd__fill_2
XFILLER_11_188 VGND VGND VPWR VPWR sky130_fd_sc_hd__decap_3
XFILLER_7_148 VGND VGND VPWR VPWR sky130_fd_sc_hd__decap_3
XFILLER_22_95 VGND VGND VPWR VPWR sky130_fd_sc_hd__fill_2
XFILLER_112_208 VGND VGND VPWR VPWR sky130_fd_sc_hd__decap_3
XFILLER_78_100 VGND VGND VPWR VPWR sky130_fd_sc_hd__decap_3
XFILLER_79_612 VGND VGND VPWR VPWR sky130_fd_sc_hd__decap_3
XFILLER_79_623 VGND VGND VPWR VPWR sky130_fd_sc_hd__decap_3
XFILLER_105_293 VGND VGND VPWR VPWR sky130_fd_sc_hd__decap_3
XFILLER_78_144 VGND VGND VPWR VPWR sky130_fd_sc_hd__fill_1
XFILLER_79_656 VGND VGND VPWR VPWR sky130_fd_sc_hd__decap_3
XFILLER_78_177 VGND VGND VPWR VPWR sky130_fd_sc_hd__decap_3
XFILLER_93_103 VGND VGND VPWR VPWR sky130_fd_sc_hd__decap_3
XFILLER_94_604 VGND VGND VPWR VPWR sky130_fd_sc_hd__decap_3
XFILLER_19_211 VGND VGND VPWR VPWR sky130_fd_sc_hd__fill_1
XFILLER_47_531 VGND VGND VPWR VPWR sky130_fd_sc_hd__fill_1
XFILLER_59_391 VGND VGND VPWR VPWR sky130_fd_sc_hd__fill_1
XFILLER_94_637 VGND VGND VPWR VPWR sky130_fd_sc_hd__decap_3
XFILLER_94_648 VGND VGND VPWR VPWR sky130_fd_sc_hd__decap_3
XFILLER_47_564 VGND VGND VPWR VPWR sky130_fd_sc_hd__decap_3
XFILLER_34_214 VGND VGND VPWR VPWR sky130_fd_sc_hd__decap_3
XFILLER_47_597 VGND VGND VPWR VPWR sky130_fd_sc_hd__decap_3
XFILLER_62_523 VGND VGND VPWR VPWR sky130_fd_sc_hd__decap_3
XFILLER_34_258 VGND VGND VPWR VPWR sky130_fd_sc_hd__decap_3
XTAP_TAPCELL_ROW_66_1048 VGND VPWR sky130_fd_sc_hd__tapvpwrvgnd_1
XFILLER_62_578 VGND VGND VPWR VPWR sky130_fd_sc_hd__decap_3
XFILLER_62_589 VGND VGND VPWR VPWR sky130_fd_sc_hd__decap_3
XTAP_TAPCELL_ROW_45_787 VGND VPWR sky130_fd_sc_hd__tapvpwrvgnd_1
XTAP_TAPCELL_ROW_17_456 VGND VPWR sky130_fd_sc_hd__tapvpwrvgnd_1
XFILLER_42_291 VGND VGND VPWR VPWR sky130_fd_sc_hd__decap_3
XFILLER_30_464 VGND VGND VPWR VPWR sky130_fd_sc_hd__decap_3
X_4630_ _4627_/Y _4629_/Y _4372_/A VGND VGND VPWR VPWR _4630_/X sky130_fd_sc_hd__a21o_2
XFILLER_30_486 VGND VGND VPWR VPWR sky130_fd_sc_hd__fill_1
X_6300_ _6586_/A VGND VGND VPWR VPWR _6300_/Y sky130_fd_sc_hd__inv_2
X_4561_ _4561_/A _4577_/B VGND VGND VPWR VPWR _7300_/D sky130_fd_sc_hd__and2_2
XFILLER_7_671 VGND VGND VPWR VPWR sky130_fd_sc_hd__fill_1
XFILLER_7_682 VGND VGND VPWR VPWR sky130_fd_sc_hd__decap_3
X_7280_ _7344_/CLK _7280_/D _6560_/Y VGND VGND VPWR VPWR _7280_/Q sky130_fd_sc_hd__dfrtp_2
Xhold605 _6835_/Q VGND VGND VPWR VPWR _6835_/D sky130_fd_sc_hd__dlygate4sd3_1
Xhold616 _6971_/Q VGND VGND VPWR VPWR _6971_/D sky130_fd_sc_hd__dlygate4sd3_1
Xhold627 _6728_/Q VGND VGND VPWR VPWR _6728_/D sky130_fd_sc_hd__dlygate4sd3_1
XFILLER_116_558 VGND VGND VPWR VPWR sky130_fd_sc_hd__fill_2
XFILLER_116_569 VGND VGND VPWR VPWR sky130_fd_sc_hd__decap_3
Xhold638 _6945_/Q VGND VGND VPWR VPWR _6945_/D sky130_fd_sc_hd__dlygate4sd3_1
Xhold649 _6921_/Q VGND VGND VPWR VPWR _6921_/D sky130_fd_sc_hd__dlygate4sd3_1
XTAP_TAPCELL_ROW_77_1177 VGND VPWR sky130_fd_sc_hd__tapvpwrvgnd_1
XFILLER_103_208 VGND VGND VPWR VPWR sky130_fd_sc_hd__decap_3
XTAP_TAPCELL_ROW_90_1333 VGND VPWR sky130_fd_sc_hd__tapvpwrvgnd_1
XFILLER_111_230 VGND VGND VPWR VPWR sky130_fd_sc_hd__decap_3
X_5113_ _5113_/A _5113_/B VGND VGND VPWR VPWR _5113_/Y sky130_fd_sc_hd__xnor2_2
XFILLER_85_615 VGND VGND VPWR VPWR sky130_fd_sc_hd__fill_1
XFILLER_85_626 VGND VGND VPWR VPWR sky130_fd_sc_hd__decap_3
XFILLER_57_328 VGND VGND VPWR VPWR sky130_fd_sc_hd__decap_3
XFILLER_69_199 VGND VGND VPWR VPWR sky130_fd_sc_hd__decap_3
XFILLER_85_659 VGND VGND VPWR VPWR sky130_fd_sc_hd__decap_3
XFILLER_97_497 VGND VGND VPWR VPWR sky130_fd_sc_hd__decap_3
X_5044_ _5044_/A _5044_/B VGND VGND VPWR VPWR _6988_/D sky130_fd_sc_hd__nor2_2
XFILLER_72_309 VGND VGND VPWR VPWR sky130_fd_sc_hd__fill_1
XFILLER_84_169 VGND VGND VPWR VPWR sky130_fd_sc_hd__decap_3
XFILLER_38_575 VGND VGND VPWR VPWR sky130_fd_sc_hd__decap_3
XFILLER_25_225 VGND VGND VPWR VPWR sky130_fd_sc_hd__decap_3
XFILLER_53_567 VGND VGND VPWR VPWR sky130_fd_sc_hd__decap_3
XFILLER_92_191 VGND VGND VPWR VPWR sky130_fd_sc_hd__decap_3
X_6995_ _7144_/CLK _6995_/D _6275_/Y VGND VGND VPWR VPWR _6995_/Q sky130_fd_sc_hd__dfrtp_2
XFILLER_25_269 VGND VGND VPWR VPWR sky130_fd_sc_hd__fill_1
XFILLER_40_206 VGND VGND VPWR VPWR sky130_fd_sc_hd__decap_3
XFILLER_40_228 VGND VGND VPWR VPWR sky130_fd_sc_hd__decap_3
X_4828_ _4970_/A1 _4810_/B _4827_/A _5033_/B2 VGND VGND VPWR VPWR _4828_/X sky130_fd_sc_hd__a22o_2
XFILLER_107_503 VGND VGND VPWR VPWR sky130_fd_sc_hd__fill_1
X_4759_ _4759_/A _4777_/B VGND VGND VPWR VPWR _4760_/B sky130_fd_sc_hd__xnor2_2
XFILLER_107_514 VGND VGND VPWR VPWR sky130_fd_sc_hd__decap_3
XFILLER_107_547 VGND VGND VPWR VPWR sky130_fd_sc_hd__decap_3
XFILLER_104_6 VGND VGND VPWR VPWR sky130_fd_sc_hd__decap_3
XFILLER_108_21 VGND VGND VPWR VPWR sky130_fd_sc_hd__decap_3
XFILLER_108_32 VGND VGND VPWR VPWR sky130_fd_sc_hd__decap_3
X_6429_ _6620_/A VGND VGND VPWR VPWR _6429_/Y sky130_fd_sc_hd__inv_2
XFILLER_115_591 VGND VGND VPWR VPWR sky130_fd_sc_hd__decap_3
XFILLER_102_241 VGND VGND VPWR VPWR sky130_fd_sc_hd__decap_3
XFILLER_48_306 VGND VGND VPWR VPWR sky130_fd_sc_hd__fill_2
XFILLER_76_604 VGND VGND VPWR VPWR sky130_fd_sc_hd__decap_3
XFILLER_76_637 VGND VGND VPWR VPWR sky130_fd_sc_hd__decap_3
XFILLER_76_648 VGND VGND VPWR VPWR sky130_fd_sc_hd__decap_3
XFILLER_29_564 VGND VGND VPWR VPWR sky130_fd_sc_hd__decap_3
XFILLER_56_350 VGND VGND VPWR VPWR sky130_fd_sc_hd__decap_3
XFILLER_63_309 VGND VGND VPWR VPWR sky130_fd_sc_hd__decap_3
XFILLER_75_158 VGND VGND VPWR VPWR sky130_fd_sc_hd__decap_3
XFILLER_75_169 VGND VGND VPWR VPWR sky130_fd_sc_hd__decap_3
XFILLER_16_203 VGND VGND VPWR VPWR sky130_fd_sc_hd__fill_1
XFILLER_29_597 VGND VGND VPWR VPWR sky130_fd_sc_hd__decap_3
XFILLER_84_681 VGND VGND VPWR VPWR sky130_fd_sc_hd__decap_3
XFILLER_91_629 VGND VGND VPWR VPWR sky130_fd_sc_hd__decap_3
Xplace309 _3618_/X VGND VGND VPWR VPWR _4969_/B sky130_fd_sc_hd__buf_2
XFILLER_16_247 VGND VGND VPWR VPWR sky130_fd_sc_hd__decap_3
XFILLER_44_578 VGND VGND VPWR VPWR sky130_fd_sc_hd__decap_3
XFILLER_44_589 VGND VGND VPWR VPWR sky130_fd_sc_hd__decap_3
XFILLER_24_280 VGND VGND VPWR VPWR sky130_fd_sc_hd__decap_3
XTAP_TAPCELL_ROW_14_415 VGND VPWR sky130_fd_sc_hd__tapvpwrvgnd_1
XTAP_TAPCELL_ROW_42_757 VGND VPWR sky130_fd_sc_hd__tapvpwrvgnd_1
XFILLER_8_424 VGND VGND VPWR VPWR sky130_fd_sc_hd__decap_3
XFILLER_69_9 VGND VGND VPWR VPWR sky130_fd_sc_hd__decap_3
XTAP_TAPCELL_ROW_113_1609 VGND VPWR sky130_fd_sc_hd__tapvpwrvgnd_1
XFILLER_113_517 VGND VGND VPWR VPWR sky130_fd_sc_hd__decap_3
XFILLER_3_151 VGND VGND VPWR VPWR sky130_fd_sc_hd__fill_1
XFILLER_4_663 VGND VGND VPWR VPWR sky130_fd_sc_hd__decap_3
XFILLER_67_615 VGND VGND VPWR VPWR sky130_fd_sc_hd__fill_1
XFILLER_67_626 VGND VGND VPWR VPWR sky130_fd_sc_hd__decap_3
XFILLER_67_659 VGND VGND VPWR VPWR sky130_fd_sc_hd__decap_3
XFILLER_54_309 VGND VGND VPWR VPWR sky130_fd_sc_hd__decap_3
XFILLER_82_607 VGND VGND VPWR VPWR sky130_fd_sc_hd__decap_3
XFILLER_74_180 VGND VGND VPWR VPWR sky130_fd_sc_hd__decap_3
XFILLER_90_640 VGND VGND VPWR VPWR sky130_fd_sc_hd__decap_3
XFILLER_90_651 VGND VGND VPWR VPWR sky130_fd_sc_hd__decap_3
XFILLER_35_567 VGND VGND VPWR VPWR sky130_fd_sc_hd__decap_3
XFILLER_90_684 VGND VGND VPWR VPWR sky130_fd_sc_hd__decap_3
X_6780_ _7378_/CLK _6780_/D VGND VGND VPWR VPWR _6780_/Q sky130_fd_sc_hd__dfxtp_2
X_3992_ _5156_/S _5587_/B VGND VGND VPWR VPWR _3992_/Y sky130_fd_sc_hd__nand2_2
XFILLER_22_217 VGND VGND VPWR VPWR sky130_fd_sc_hd__decap_3
XFILLER_62_397 VGND VGND VPWR VPWR sky130_fd_sc_hd__decap_3
X_5731_ _7371_/Q hold921/X _5735_/S VGND VGND VPWR VPWR _6715_/D sky130_fd_sc_hd__mux2_2
X_5662_ _5662_/A _5662_/B _5662_/C _5661_/X VGND VGND VPWR VPWR _5663_/D sky130_fd_sc_hd__or4b_4
XFILLER_30_283 VGND VGND VPWR VPWR sky130_fd_sc_hd__decap_3
X_7401_ _7405_/CLK _7401_/D _6681_/Y VGND VGND VPWR VPWR _7401_/Q sky130_fd_sc_hd__dfrtp_2
X_5593_ _5593_/A _5593_/B VGND VGND VPWR VPWR _7031_/D sky130_fd_sc_hd__or2_2
X_4613_ _4614_/B _4613_/B _5113_/A VGND VGND VPWR VPWR _4617_/B sky130_fd_sc_hd__and3_2
X_7332_ _7332_/CLK _7332_/D _6612_/Y VGND VGND VPWR VPWR _7332_/Q sky130_fd_sc_hd__dfrtp_2
X_4544_ _4544_/A _4563_/B VGND VGND VPWR VPWR _7308_/D sky130_fd_sc_hd__and2_2
X_7263_ _7362_/CLK _7263_/D _6543_/Y VGND VGND VPWR VPWR _7263_/Q sky130_fd_sc_hd__dfrtp_2
XFILLER_104_528 VGND VGND VPWR VPWR sky130_fd_sc_hd__decap_3
XFILLER_104_539 VGND VGND VPWR VPWR sky130_fd_sc_hd__decap_3
XFILLER_116_377 VGND VGND VPWR VPWR sky130_fd_sc_hd__decap_3
XFILLER_116_399 VGND VGND VPWR VPWR sky130_fd_sc_hd__decap_3
X_7194_ _7353_/CLK _7194_/D _6474_/Y VGND VGND VPWR VPWR _7194_/Q sky130_fd_sc_hd__dfrtp_2
X_3426_ _3589_/A _3591_/A _3589_/B _3590_/C VGND VGND VPWR VPWR _3427_/B sky130_fd_sc_hd__or4_4
XFILLER_58_604 VGND VGND VPWR VPWR sky130_fd_sc_hd__decap_3
X_3357_ _4537_/B VGND VGND VPWR VPWR _3449_/A sky130_fd_sc_hd__inv_6
XFILLER_112_572 VGND VGND VPWR VPWR sky130_fd_sc_hd__decap_3
XFILLER_58_637 VGND VGND VPWR VPWR sky130_fd_sc_hd__decap_3
XFILLER_58_648 VGND VGND VPWR VPWR sky130_fd_sc_hd__decap_3
Xhold1102 _7151_/Q VGND VGND VPWR VPWR _5360_/A0 sky130_fd_sc_hd__dlygate4sd3_1
Xhold1113 _7167_/Q VGND VGND VPWR VPWR _5327_/A0 sky130_fd_sc_hd__dlygate4sd3_1
Xhold1124 _7383_/Q VGND VGND VPWR VPWR _3875_/A1 sky130_fd_sc_hd__dlygate4sd3_1
XFILLER_45_309 VGND VGND VPWR VPWR sky130_fd_sc_hd__decap_3
Xhold1135 _7229_/Q VGND VGND VPWR VPWR _5198_/A sky130_fd_sc_hd__dlygate4sd3_1
Xhold1146 _7126_/Q VGND VGND VPWR VPWR _5415_/A0 sky130_fd_sc_hd__dlygate4sd3_1
Xhold1157 _7319_/Q VGND VGND VPWR VPWR _4520_/A0 sky130_fd_sc_hd__dlygate4sd3_1
X_5027_ _5092_/C _5024_/X _6990_/D _5666_/A VGND VGND VPWR VPWR _5027_/X sky130_fd_sc_hd__a22o_2
XFILLER_66_681 VGND VGND VPWR VPWR sky130_fd_sc_hd__decap_3
XFILLER_72_106 VGND VGND VPWR VPWR sky130_fd_sc_hd__decap_3
XFILLER_73_629 VGND VGND VPWR VPWR sky130_fd_sc_hd__decap_3
Xhold1168 _7158_/Q VGND VGND VPWR VPWR _5346_/A0 sky130_fd_sc_hd__dlygate4sd3_1
Xhold1179 _7160_/Q VGND VGND VPWR VPWR _5342_/A0 sky130_fd_sc_hd__dlygate4sd3_1
XFILLER_26_556 VGND VGND VPWR VPWR sky130_fd_sc_hd__decap_3
XFILLER_26_589 VGND VGND VPWR VPWR sky130_fd_sc_hd__decap_3
XFILLER_53_364 VGND VGND VPWR VPWR sky130_fd_sc_hd__fill_1
XFILLER_80_150 VGND VGND VPWR VPWR sky130_fd_sc_hd__fill_1
XFILLER_81_662 VGND VGND VPWR VPWR sky130_fd_sc_hd__decap_3
XFILLER_81_673 VGND VGND VPWR VPWR sky130_fd_sc_hd__decap_3
XFILLER_110_44 VGND VGND VPWR VPWR sky130_fd_sc_hd__decap_3
XFILLER_13_228 VGND VGND VPWR VPWR sky130_fd_sc_hd__fill_1
XFILLER_41_548 VGND VGND VPWR VPWR sky130_fd_sc_hd__decap_3
XFILLER_53_386 VGND VGND VPWR VPWR sky130_fd_sc_hd__decap_3
XFILLER_80_183 VGND VGND VPWR VPWR sky130_fd_sc_hd__decap_3
X_6978_ _6978_/CLK _6978_/D VGND VGND VPWR VPWR _6978_/Q sky130_fd_sc_hd__dfxtp_2
XFILLER_110_77 VGND VGND VPWR VPWR sky130_fd_sc_hd__decap_3
XFILLER_21_261 VGND VGND VPWR VPWR sky130_fd_sc_hd__decap_3
XFILLER_107_300 VGND VGND VPWR VPWR sky130_fd_sc_hd__decap_3
XFILLER_107_322 VGND VGND VPWR VPWR sky130_fd_sc_hd__decap_3
XFILLER_5_438 VGND VGND VPWR VPWR sky130_fd_sc_hd__fill_1
XFILLER_5_449 VGND VGND VPWR VPWR sky130_fd_sc_hd__decap_3
XFILLER_107_377 VGND VGND VPWR VPWR sky130_fd_sc_hd__fill_2
XFILLER_79_57 VGND VGND VPWR VPWR sky130_fd_sc_hd__decap_3
XFILLER_107_399 VGND VGND VPWR VPWR sky130_fd_sc_hd__fill_1
XFILLER_1_644 VGND VGND VPWR VPWR sky130_fd_sc_hd__decap_3
Xhold991 _7185_/Q VGND VGND VPWR VPWR hold991/X sky130_fd_sc_hd__dlygate4sd3_1
Xhold980 _7325_/Q VGND VGND VPWR VPWR hold980/X sky130_fd_sc_hd__dlygate4sd3_1
XFILLER_103_550 VGND VGND VPWR VPWR sky130_fd_sc_hd__decap_3
XFILLER_103_561 VGND VGND VPWR VPWR sky130_fd_sc_hd__decap_3
XFILLER_49_615 VGND VGND VPWR VPWR sky130_fd_sc_hd__fill_1
XFILLER_95_23 VGND VGND VPWR VPWR sky130_fd_sc_hd__decap_3
XFILLER_0_165 VGND VGND VPWR VPWR sky130_fd_sc_hd__decap_3
XFILLER_103_594 VGND VGND VPWR VPWR sky130_fd_sc_hd__decap_3
XFILLER_1_688 VGND VGND VPWR VPWR sky130_fd_sc_hd__decap_3
XFILLER_49_626 VGND VGND VPWR VPWR sky130_fd_sc_hd__decap_3
XFILLER_36_309 VGND VGND VPWR VPWR sky130_fd_sc_hd__decap_3
XFILLER_48_136 VGND VGND VPWR VPWR sky130_fd_sc_hd__decap_3
XFILLER_48_158 VGND VGND VPWR VPWR sky130_fd_sc_hd__fill_2
XFILLER_49_659 VGND VGND VPWR VPWR sky130_fd_sc_hd__decap_3
XFILLER_64_607 VGND VGND VPWR VPWR sky130_fd_sc_hd__decap_3
XFILLER_95_78 VGND VGND VPWR VPWR sky130_fd_sc_hd__decap_3
XFILLER_29_361 VGND VGND VPWR VPWR sky130_fd_sc_hd__decap_3
XTAP_TAPCELL_ROW_47_816 VGND VPWR sky130_fd_sc_hd__tapvpwrvgnd_1
XFILLER_17_523 VGND VGND VPWR VPWR sky130_fd_sc_hd__decap_3
XFILLER_17_556 VGND VGND VPWR VPWR sky130_fd_sc_hd__decap_3
XFILLER_72_640 VGND VGND VPWR VPWR sky130_fd_sc_hd__decap_3
XFILLER_17_567 VGND VGND VPWR VPWR sky130_fd_sc_hd__decap_3
XFILLER_44_375 VGND VGND VPWR VPWR sky130_fd_sc_hd__decap_3
XFILLER_72_651 VGND VGND VPWR VPWR sky130_fd_sc_hd__decap_3
XFILLER_72_684 VGND VGND VPWR VPWR sky130_fd_sc_hd__decap_3
XTAP_TAPCELL_ROW_63_1007 VGND VPWR sky130_fd_sc_hd__tapvpwrvgnd_1
XFILLER_44_386 VGND VGND VPWR VPWR sky130_fd_sc_hd__decap_3
XFILLER_44_71 VGND VGND VPWR VPWR sky130_fd_sc_hd__fill_1
XFILLER_71_172 VGND VGND VPWR VPWR sky130_fd_sc_hd__decap_3
XTAP_TAPCELL_ROW_27_573 VGND VPWR sky130_fd_sc_hd__tapvpwrvgnd_1
XFILLER_40_581 VGND VGND VPWR VPWR sky130_fd_sc_hd__decap_3
XFILLER_12_294 VGND VGND VPWR VPWR sky130_fd_sc_hd__fill_2
XFILLER_40_592 VGND VGND VPWR VPWR sky130_fd_sc_hd__decap_3
XFILLER_5_21 VGND VGND VPWR VPWR sky130_fd_sc_hd__fill_1
XFILLER_8_298 VGND VGND VPWR VPWR sky130_fd_sc_hd__fill_1
Xoutput518 _7009_/Q VGND VGND VPWR VPWR pc_out[0] sky130_fd_sc_hd__clkdlybuf4s25_1
Xoutput507 _5648_/A VGND VGND VPWR VPWR instruction_out[27] sky130_fd_sc_hd__clkdlybuf4s25_1
XFILLER_113_303 VGND VGND VPWR VPWR sky130_fd_sc_hd__decap_3
XFILLER_4_460 VGND VGND VPWR VPWR sky130_fd_sc_hd__decap_3
Xoutput529 _7010_/Q VGND VGND VPWR VPWR pc_out[1] sky130_fd_sc_hd__clkdlybuf4s25_1
XTAP_TAPCELL_ROW_74_1136 VGND VPWR sky130_fd_sc_hd__tapvpwrvgnd_1
XFILLER_99_526 VGND VGND VPWR VPWR sky130_fd_sc_hd__decap_3
X_4260_ _7262_/Q _4356_/A2 _3958_/S _7326_/Q VGND VGND VPWR VPWR _4264_/A sky130_fd_sc_hd__a22o_2
XFILLER_99_559 VGND VGND VPWR VPWR sky130_fd_sc_hd__fill_1
XFILLER_67_401 VGND VGND VPWR VPWR sky130_fd_sc_hd__decap_3
XFILLER_79_250 VGND VGND VPWR VPWR sky130_fd_sc_hd__decap_3
XFILLER_86_209 VGND VGND VPWR VPWR sky130_fd_sc_hd__fill_1
X_4191_ _7071_/Q _4265_/B _4205_/A VGND VGND VPWR VPWR _4637_/C sky130_fd_sc_hd__o21a_2
XFILLER_67_434 VGND VGND VPWR VPWR sky130_fd_sc_hd__decap_3
XFILLER_79_272 VGND VGND VPWR VPWR sky130_fd_sc_hd__decap_3
XFILLER_67_445 VGND VGND VPWR VPWR sky130_fd_sc_hd__decap_3
XFILLER_94_231 VGND VGND VPWR VPWR sky130_fd_sc_hd__decap_3
XFILLER_94_253 VGND VGND VPWR VPWR sky130_fd_sc_hd__decap_3
XFILLER_48_681 VGND VGND VPWR VPWR sky130_fd_sc_hd__decap_3
XFILLER_55_629 VGND VGND VPWR VPWR sky130_fd_sc_hd__decap_3
XFILLER_82_415 VGND VGND VPWR VPWR sky130_fd_sc_hd__decap_3
XFILLER_54_139 VGND VGND VPWR VPWR sky130_fd_sc_hd__fill_1
XFILLER_82_448 VGND VGND VPWR VPWR sky130_fd_sc_hd__fill_1
X_6901_ _6978_/CLK _6901_/D VGND VGND VPWR VPWR _6901_/Q sky130_fd_sc_hd__dfxtp_2
XFILLER_35_364 VGND VGND VPWR VPWR sky130_fd_sc_hd__fill_2
XFILLER_63_662 VGND VGND VPWR VPWR sky130_fd_sc_hd__decap_3
XFILLER_63_673 VGND VGND VPWR VPWR sky130_fd_sc_hd__decap_3
X_6832_ clkload9/A _6832_/D VGND VGND VPWR VPWR _6832_/Q sky130_fd_sc_hd__dfxtp_2
XFILLER_23_537 VGND VGND VPWR VPWR sky130_fd_sc_hd__decap_3
XFILLER_50_312 VGND VGND VPWR VPWR sky130_fd_sc_hd__decap_3
XTAP_TAPCELL_ROW_85_1276 VGND VPWR sky130_fd_sc_hd__tapvpwrvgnd_1
XFILLER_50_334 VGND VGND VPWR VPWR sky130_fd_sc_hd__decap_3
X_6763_ _6968_/CLK _6763_/D VGND VGND VPWR VPWR _6763_/Q sky130_fd_sc_hd__dfxtp_2
X_3975_ _7353_/Q _4517_/A0 _3975_/S VGND VGND VPWR VPWR _7353_/D sky130_fd_sc_hd__mux2_2
XFILLER_10_209 VGND VGND VPWR VPWR sky130_fd_sc_hd__decap_3
XFILLER_31_570 VGND VGND VPWR VPWR sky130_fd_sc_hd__decap_3
X_6694_ clkload7/A _6694_/D VGND VGND VPWR VPWR _6694_/Q sky130_fd_sc_hd__dfxtp_2
XFILLER_109_609 VGND VGND VPWR VPWR sky130_fd_sc_hd__decap_3
X_5645_ _3561_/A _5129_/B _3519_/B _5644_/X VGND VGND VPWR VPWR _5645_/X sky130_fd_sc_hd__o31a_2
X_5576_ hold941/X _5587_/B _5015_/X VGND VGND VPWR VPWR _7041_/D sky130_fd_sc_hd__a21o_2
XFILLER_116_152 VGND VGND VPWR VPWR sky130_fd_sc_hd__decap_3
X_7315_ _7350_/CLK _7315_/D _6595_/Y VGND VGND VPWR VPWR _7315_/Q sky130_fd_sc_hd__dfrtp_2
XFILLER_104_336 VGND VGND VPWR VPWR sky130_fd_sc_hd__decap_3
X_7246_ _7374_/CLK _7246_/D _6526_/Y VGND VGND VPWR VPWR _7246_/Q sky130_fd_sc_hd__dfrtp_2
X_4458_ _4458_/A _4039_/A VGND VGND VPWR VPWR _4458_/X sky130_fd_sc_hd__or2b_2
X_7177_ _7405_/CLK _7177_/D _6457_/Y VGND VGND VPWR VPWR _7177_/Q sky130_fd_sc_hd__dfrtp_2
X_3409_ _3449_/A _3449_/B _3421_/C _3409_/D VGND VGND VPWR VPWR _3409_/X sky130_fd_sc_hd__and4_2
XFILLER_105_33 VGND VGND VPWR VPWR sky130_fd_sc_hd__decap_3
XFILLER_58_401 VGND VGND VPWR VPWR sky130_fd_sc_hd__fill_1
X_4389_ _7081_/Q _4102_/B _4432_/B1 _4388_/X VGND VGND VPWR VPWR _4396_/A sky130_fd_sc_hd__o211ai_2
XFILLER_98_592 VGND VGND VPWR VPWR sky130_fd_sc_hd__decap_3
XFILLER_98_581 VGND VGND VPWR VPWR sky130_fd_sc_hd__decap_3
XFILLER_100_531 VGND VGND VPWR VPWR sky130_fd_sc_hd__fill_1
XFILLER_100_542 VGND VGND VPWR VPWR sky130_fd_sc_hd__decap_3
XFILLER_105_66 VGND VGND VPWR VPWR sky130_fd_sc_hd__decap_3
XFILLER_112_391 VGND VGND VPWR VPWR sky130_fd_sc_hd__decap_3
XFILLER_46_607 VGND VGND VPWR VPWR sky130_fd_sc_hd__decap_3
XFILLER_58_456 VGND VGND VPWR VPWR sky130_fd_sc_hd__fill_2
XFILLER_58_467 VGND VGND VPWR VPWR sky130_fd_sc_hd__decap_3
XFILLER_65_15 VGND VGND VPWR VPWR sky130_fd_sc_hd__decap_3
XFILLER_100_575 VGND VGND VPWR VPWR sky130_fd_sc_hd__decap_3
XFILLER_18_309 VGND VGND VPWR VPWR sky130_fd_sc_hd__decap_3
XFILLER_54_640 VGND VGND VPWR VPWR sky130_fd_sc_hd__decap_3
XFILLER_26_353 VGND VGND VPWR VPWR sky130_fd_sc_hd__decap_3
XFILLER_54_651 VGND VGND VPWR VPWR sky130_fd_sc_hd__decap_3
XFILLER_14_526 VGND VGND VPWR VPWR sky130_fd_sc_hd__decap_3
XFILLER_14_548 VGND VGND VPWR VPWR sky130_fd_sc_hd__decap_3
XFILLER_41_312 VGND VGND VPWR VPWR sky130_fd_sc_hd__decap_3
XFILLER_53_172 VGND VGND VPWR VPWR sky130_fd_sc_hd__decap_3
XFILLER_54_684 VGND VGND VPWR VPWR sky130_fd_sc_hd__decap_3
XFILLER_81_481 VGND VGND VPWR VPWR sky130_fd_sc_hd__fill_1
XFILLER_41_334 VGND VGND VPWR VPWR sky130_fd_sc_hd__fill_2
XFILLER_41_345 VGND VGND VPWR VPWR sky130_fd_sc_hd__decap_3
XFILLER_41_367 VGND VGND VPWR VPWR sky130_fd_sc_hd__decap_3
XFILLER_81_69 VGND VGND VPWR VPWR sky130_fd_sc_hd__decap_3
XTAP_TAPCELL_ROW_24_543 VGND VPWR sky130_fd_sc_hd__tapvpwrvgnd_1
XFILLER_14_52 VGND VGND VPWR VPWR sky130_fd_sc_hd__fill_2
XFILLER_41_389 VGND VGND VPWR VPWR sky130_fd_sc_hd__decap_3
XTAP_TAPCELL_ROW_52_874 VGND VPWR sky130_fd_sc_hd__tapvpwrvgnd_1
XFILLER_14_74 VGND VGND VPWR VPWR sky130_fd_sc_hd__fill_2
XFILLER_14_85 VGND VGND VPWR VPWR sky130_fd_sc_hd__fill_2
XFILLER_22_592 VGND VGND VPWR VPWR sky130_fd_sc_hd__decap_3
XFILLER_5_202 VGND VGND VPWR VPWR sky130_fd_sc_hd__decap_3
XFILLER_108_631 VGND VGND VPWR VPWR sky130_fd_sc_hd__decap_3
XFILLER_107_152 VGND VGND VPWR VPWR sky130_fd_sc_hd__decap_3
XFILLER_108_675 VGND VGND VPWR VPWR sky130_fd_sc_hd__decap_3
XFILLER_5_257 VGND VGND VPWR VPWR sky130_fd_sc_hd__decap_3
XFILLER_110_306 VGND VGND VPWR VPWR sky130_fd_sc_hd__fill_2
XFILLER_96_518 VGND VGND VPWR VPWR sky130_fd_sc_hd__decap_3
XFILLER_1_463 VGND VGND VPWR VPWR sky130_fd_sc_hd__decap_3
XFILLER_89_570 VGND VGND VPWR VPWR sky130_fd_sc_hd__decap_3
XFILLER_1_496 VGND VGND VPWR VPWR sky130_fd_sc_hd__decap_3
XFILLER_49_445 VGND VGND VPWR VPWR sky130_fd_sc_hd__decap_3
XFILLER_49_467 VGND VGND VPWR VPWR sky130_fd_sc_hd__decap_3
XFILLER_76_242 VGND VGND VPWR VPWR sky130_fd_sc_hd__decap_3
XFILLER_36_117 VGND VGND VPWR VPWR sky130_fd_sc_hd__fill_2
XFILLER_37_629 VGND VGND VPWR VPWR sky130_fd_sc_hd__decap_3
XFILLER_49_478 VGND VGND VPWR VPWR sky130_fd_sc_hd__decap_3
XFILLER_64_415 VGND VGND VPWR VPWR sky130_fd_sc_hd__decap_3
XFILLER_76_253 VGND VGND VPWR VPWR sky130_fd_sc_hd__decap_3
XFILLER_76_275 VGND VGND VPWR VPWR sky130_fd_sc_hd__decap_3
XFILLER_76_286 VGND VGND VPWR VPWR sky130_fd_sc_hd__decap_3
XFILLER_29_180 VGND VGND VPWR VPWR sky130_fd_sc_hd__decap_3
XFILLER_36_139 VGND VGND VPWR VPWR sky130_fd_sc_hd__fill_1
XFILLER_91_212 VGND VGND VPWR VPWR sky130_fd_sc_hd__decap_3
XFILLER_91_234 VGND VGND VPWR VPWR sky130_fd_sc_hd__decap_3
XFILLER_17_364 VGND VGND VPWR VPWR sky130_fd_sc_hd__decap_3
XFILLER_45_662 VGND VGND VPWR VPWR sky130_fd_sc_hd__decap_3
XFILLER_45_673 VGND VGND VPWR VPWR sky130_fd_sc_hd__decap_3
XFILLER_51_109 VGND VGND VPWR VPWR sky130_fd_sc_hd__decap_3
XFILLER_32_301 VGND VGND VPWR VPWR sky130_fd_sc_hd__decap_3
XFILLER_32_312 VGND VGND VPWR VPWR sky130_fd_sc_hd__fill_2
XFILLER_44_161 VGND VGND VPWR VPWR sky130_fd_sc_hd__fill_2
XFILLER_44_183 VGND VGND VPWR VPWR sky130_fd_sc_hd__decap_3
XFILLER_55_92 VGND VGND VPWR VPWR sky130_fd_sc_hd__fill_2
XFILLER_60_610 VGND VGND VPWR VPWR sky130_fd_sc_hd__decap_3
XFILLER_91_289 VGND VGND VPWR VPWR sky130_fd_sc_hd__decap_3
XFILLER_60_643 VGND VGND VPWR VPWR sky130_fd_sc_hd__fill_1
XFILLER_60_654 VGND VGND VPWR VPWR sky130_fd_sc_hd__decap_3
XFILLER_13_570 VGND VGND VPWR VPWR sky130_fd_sc_hd__decap_3
XFILLER_32_389 VGND VGND VPWR VPWR sky130_fd_sc_hd__fill_1
XFILLER_60_687 VGND VGND VPWR VPWR sky130_fd_sc_hd__decap_3
X_3760_ _6933_/Q _3768_/A2 _3917_/A2 _6707_/Q VGND VGND VPWR VPWR _3760_/X sky130_fd_sc_hd__a22o_2
XFILLER_9_541 VGND VGND VPWR VPWR sky130_fd_sc_hd__decap_3
X_3691_ _6941_/Q _3768_/A2 _3918_/B1 _6805_/Q VGND VGND VPWR VPWR _3691_/X sky130_fd_sc_hd__a22o_2
XFILLER_9_585 VGND VGND VPWR VPWR sky130_fd_sc_hd__decap_3
XFILLER_65_3 VGND VGND VPWR VPWR sky130_fd_sc_hd__decap_3
XFILLER_114_601 VGND VGND VPWR VPWR sky130_fd_sc_hd__decap_3
XFILLER_113_111 VGND VGND VPWR VPWR sky130_fd_sc_hd__fill_1
XFILLER_114_634 VGND VGND VPWR VPWR sky130_fd_sc_hd__decap_3
XFILLER_114_645 VGND VGND VPWR VPWR sky130_fd_sc_hd__decap_3
X_7100_ _7328_/CLK _7100_/D _6380_/Y VGND VGND VPWR VPWR _7100_/Q sky130_fd_sc_hd__dfrtp_2
X_5292_ _5292_/A0 _4470_/X _5292_/S VGND VGND VPWR VPWR _7183_/D sky130_fd_sc_hd__mux2_2
X_4312_ _4394_/A _4312_/B _4311_/X VGND VGND VPWR VPWR _4313_/D sky130_fd_sc_hd__or3b_2
XFILLER_99_334 VGND VGND VPWR VPWR sky130_fd_sc_hd__fill_2
XFILLER_114_678 VGND VGND VPWR VPWR sky130_fd_sc_hd__decap_3
X_7031_ _7355_/CLK _7031_/D _6311_/Y VGND VGND VPWR VPWR _7031_/Q sky130_fd_sc_hd__dfrtp_2
X_4243_ _4620_/A _5032_/A VGND VGND VPWR VPWR _4243_/Y sky130_fd_sc_hd__nor2_2
XFILLER_113_199 VGND VGND VPWR VPWR sky130_fd_sc_hd__decap_3
XFILLER_28_607 VGND VGND VPWR VPWR sky130_fd_sc_hd__decap_3
X_4174_ _7296_/Q _4505_/S _4261_/A2 _7360_/Q VGND VGND VPWR VPWR _4174_/X sky130_fd_sc_hd__a22o_2
XFILLER_67_253 VGND VGND VPWR VPWR sky130_fd_sc_hd__decap_3
XFILLER_95_573 VGND VGND VPWR VPWR sky130_fd_sc_hd__decap_3
XFILLER_27_128 VGND VGND VPWR VPWR sky130_fd_sc_hd__decap_3
XFILLER_36_640 VGND VGND VPWR VPWR sky130_fd_sc_hd__decap_3
XFILLER_36_651 VGND VGND VPWR VPWR sky130_fd_sc_hd__decap_3
XFILLER_82_245 VGND VGND VPWR VPWR sky130_fd_sc_hd__decap_3
XFILLER_82_256 VGND VGND VPWR VPWR sky130_fd_sc_hd__fill_1
XFILLER_36_684 VGND VGND VPWR VPWR sky130_fd_sc_hd__decap_3
XFILLER_51_632 VGND VGND VPWR VPWR sky130_fd_sc_hd__decap_3
XFILLER_63_481 VGND VGND VPWR VPWR sky130_fd_sc_hd__fill_2
XFILLER_23_345 VGND VGND VPWR VPWR sky130_fd_sc_hd__fill_2
XFILLER_50_120 VGND VGND VPWR VPWR sky130_fd_sc_hd__decap_3
XFILLER_51_665 VGND VGND VPWR VPWR sky130_fd_sc_hd__decap_3
X_6815_ _6970_/CLK _6815_/D VGND VGND VPWR VPWR _6815_/Q sky130_fd_sc_hd__dfxtp_2
XFILLER_11_529 VGND VGND VPWR VPWR sky130_fd_sc_hd__decap_3
XFILLER_51_676 VGND VGND VPWR VPWR sky130_fd_sc_hd__decap_3
X_6746_ _6954_/CLK _6746_/D VGND VGND VPWR VPWR _6746_/Q sky130_fd_sc_hd__dfxtp_2
XTAP_TAPCELL_ROW_21_502 VGND VPWR sky130_fd_sc_hd__tapvpwrvgnd_1
XFILLER_50_197 VGND VGND VPWR VPWR sky130_fd_sc_hd__decap_3
X_3958_ _7361_/Q _4501_/A0 _3958_/S VGND VGND VPWR VPWR _7361_/D sky130_fd_sc_hd__mux2_2
XFILLER_109_417 VGND VGND VPWR VPWR sky130_fd_sc_hd__decap_3
X_6677_ _6686_/A VGND VGND VPWR VPWR _6677_/Y sky130_fd_sc_hd__inv_2
X_3889_ _6834_/Q _3889_/A2 _3889_/B1 _6829_/Q _3888_/X VGND VGND VPWR VPWR _3889_/X
+ sky130_fd_sc_hd__a221o_2
XTAP_TAPCELL_ROW_98_1423 VGND VPWR sky130_fd_sc_hd__tapvpwrvgnd_1
X_5628_ _5628_/A _5633_/B VGND VGND VPWR VPWR _7014_/D sky130_fd_sc_hd__or2_2
XFILLER_105_612 VGND VGND VPWR VPWR sky130_fd_sc_hd__decap_3
XFILLER_105_623 VGND VGND VPWR VPWR sky130_fd_sc_hd__decap_3
XFILLER_105_656 VGND VGND VPWR VPWR sky130_fd_sc_hd__decap_3
XFILLER_116_21 VGND VGND VPWR VPWR sky130_fd_sc_hd__decap_3
XFILLER_78_518 VGND VGND VPWR VPWR sky130_fd_sc_hd__decap_3
XFILLER_116_43 VGND VGND VPWR VPWR sky130_fd_sc_hd__decap_3
X_7229_ _7328_/CLK _7229_/D _6509_/Y VGND VGND VPWR VPWR _7229_/Q sky130_fd_sc_hd__dfrtp_2
XFILLER_76_58 VGND VGND VPWR VPWR sky130_fd_sc_hd__decap_3
XFILLER_86_551 VGND VGND VPWR VPWR sky130_fd_sc_hd__decap_3
XFILLER_19_629 VGND VGND VPWR VPWR sky130_fd_sc_hd__decap_3
XFILLER_58_253 VGND VGND VPWR VPWR sky130_fd_sc_hd__fill_2
XFILLER_86_584 VGND VGND VPWR VPWR sky130_fd_sc_hd__decap_3
XTAP_TAPCELL_ROW_29_602 VGND VPWR sky130_fd_sc_hd__tapvpwrvgnd_1
XFILLER_86_595 VGND VGND VPWR VPWR sky130_fd_sc_hd__decap_3
XTAP_TAPCELL_ROW_57_933 VGND VPWR sky130_fd_sc_hd__tapvpwrvgnd_1
XFILLER_27_662 VGND VGND VPWR VPWR sky130_fd_sc_hd__decap_3
XFILLER_61_407 VGND VGND VPWR VPWR sky130_fd_sc_hd__decap_3
XFILLER_92_35 VGND VGND VPWR VPWR sky130_fd_sc_hd__decap_3
XTAP_TAPCELL_ROW_1_260 VGND VPWR sky130_fd_sc_hd__tapvpwrvgnd_1
XTAP_TAPCELL_ROW_107_1541 VGND VPWR sky130_fd_sc_hd__tapvpwrvgnd_1
XTAP_TAPCELL_ROW_107_1530 VGND VPWR sky130_fd_sc_hd__tapvpwrvgnd_1
XFILLER_14_301 VGND VGND VPWR VPWR sky130_fd_sc_hd__decap_3
XFILLER_27_673 VGND VGND VPWR VPWR sky130_fd_sc_hd__decap_3
XFILLER_42_610 VGND VGND VPWR VPWR sky130_fd_sc_hd__decap_3
XFILLER_14_356 VGND VGND VPWR VPWR sky130_fd_sc_hd__decap_3
XFILLER_42_643 VGND VGND VPWR VPWR sky130_fd_sc_hd__fill_1
XFILLER_42_654 VGND VGND VPWR VPWR sky130_fd_sc_hd__decap_3
XTAP_TAPCELL_ROW_37_690 VGND VPWR sky130_fd_sc_hd__tapvpwrvgnd_1
XPHY_EDGE_ROW_1_Left_118 VGND VGND VPWR VPWR sky130_fd_sc_hd__decap_3
XFILLER_42_687 VGND VGND VPWR VPWR sky130_fd_sc_hd__decap_3
XFILLER_41_186 VGND VGND VPWR VPWR sky130_fd_sc_hd__decap_3
XFILLER_10_551 VGND VGND VPWR VPWR sky130_fd_sc_hd__decap_3
XFILLER_10_584 VGND VGND VPWR VPWR sky130_fd_sc_hd__decap_3
XFILLER_10_595 VGND VGND VPWR VPWR sky130_fd_sc_hd__decap_3
XFILLER_6_522 VGND VGND VPWR VPWR sky130_fd_sc_hd__decap_3
XFILLER_6_533 VGND VGND VPWR VPWR sky130_fd_sc_hd__decap_3
XFILLER_41_94 VGND VGND VPWR VPWR sky130_fd_sc_hd__fill_1
XFILLER_6_566 VGND VGND VPWR VPWR sky130_fd_sc_hd__decap_3
XFILLER_108_472 VGND VGND VPWR VPWR sky130_fd_sc_hd__decap_3
XFILLER_108_483 VGND VGND VPWR VPWR sky130_fd_sc_hd__decap_3
XTAP_TAPCELL_ROW_9_360 VGND VPWR sky130_fd_sc_hd__tapvpwrvgnd_1
XTAP_TAPCELL_ROW_71_1106 VGND VPWR sky130_fd_sc_hd__tapvpwrvgnd_1
XFILLER_111_615 VGND VGND VPWR VPWR sky130_fd_sc_hd__fill_1
XFILLER_111_626 VGND VGND VPWR VPWR sky130_fd_sc_hd__decap_3
XFILLER_69_529 VGND VGND VPWR VPWR sky130_fd_sc_hd__decap_3
XFILLER_111_659 VGND VGND VPWR VPWR sky130_fd_sc_hd__decap_3
XFILLER_49_231 VGND VGND VPWR VPWR sky130_fd_sc_hd__decap_3
XFILLER_77_540 VGND VGND VPWR VPWR sky130_fd_sc_hd__decap_3
XFILLER_37_404 VGND VGND VPWR VPWR sky130_fd_sc_hd__decap_3
XFILLER_77_573 VGND VGND VPWR VPWR sky130_fd_sc_hd__decap_3
XFILLER_2_88 VGND VGND VPWR VPWR sky130_fd_sc_hd__fill_2
XFILLER_18_640 VGND VGND VPWR VPWR sky130_fd_sc_hd__decap_3
XFILLER_18_651 VGND VGND VPWR VPWR sky130_fd_sc_hd__decap_3
XFILLER_64_256 VGND VGND VPWR VPWR sky130_fd_sc_hd__decap_3
XFILLER_92_554 VGND VGND VPWR VPWR sky130_fd_sc_hd__decap_3
XTAP_TAPCELL_ROW_69_1079 VGND VPWR sky130_fd_sc_hd__tapvpwrvgnd_1
XFILLER_18_684 VGND VGND VPWR VPWR sky130_fd_sc_hd__decap_3
XFILLER_64_289 VGND VGND VPWR VPWR sky130_fd_sc_hd__decap_3
XFILLER_92_587 VGND VGND VPWR VPWR sky130_fd_sc_hd__fill_1
XFILLER_92_598 VGND VGND VPWR VPWR sky130_fd_sc_hd__decap_3
X_4930_ _6995_/Q _4963_/A _6996_/Q VGND VGND VPWR VPWR _4931_/B sky130_fd_sc_hd__a21oi_2
XFILLER_17_183 VGND VGND VPWR VPWR sky130_fd_sc_hd__fill_1
XFILLER_33_632 VGND VGND VPWR VPWR sky130_fd_sc_hd__decap_3
XFILLER_33_665 VGND VGND VPWR VPWR sky130_fd_sc_hd__decap_3
XFILLER_60_440 VGND VGND VPWR VPWR sky130_fd_sc_hd__decap_3
X_4861_ _6998_/Q _6999_/Q _4912_/A _7000_/Q VGND VGND VPWR VPWR _4862_/B sky130_fd_sc_hd__a31o_2
XTAP_TAPCELL_ROW_82_1235 VGND VPWR sky130_fd_sc_hd__tapvpwrvgnd_1
XFILLER_33_676 VGND VGND VPWR VPWR sky130_fd_sc_hd__decap_3
XFILLER_60_462 VGND VGND VPWR VPWR sky130_fd_sc_hd__fill_1
X_6600_ _6626_/A VGND VGND VPWR VPWR _6600_/Y sky130_fd_sc_hd__inv_2
X_3812_ _3725_/X _3804_/X _3806_/X _3728_/Y _3811_/X VGND VGND VPWR VPWR _3812_/X
+ sky130_fd_sc_hd__a221o_2
XFILLER_20_337 VGND VGND VPWR VPWR sky130_fd_sc_hd__decap_3
XFILLER_32_175 VGND VGND VPWR VPWR sky130_fd_sc_hd__decap_3
XFILLER_32_197 VGND VGND VPWR VPWR sky130_fd_sc_hd__decap_3
XFILLER_60_495 VGND VGND VPWR VPWR sky130_fd_sc_hd__fill_1
X_4792_ _4997_/A1 _7004_/D _4777_/X _4791_/Y VGND VGND VPWR VPWR _4792_/X sky130_fd_sc_hd__a211o_2
X_6531_ _6625_/A VGND VGND VPWR VPWR _6531_/Y sky130_fd_sc_hd__inv_2
X_3743_ _6848_/Q _3892_/A2 _3891_/A2 _6838_/Q _3742_/X VGND VGND VPWR VPWR _3743_/X
+ sky130_fd_sc_hd__a221o_2
X_6462_ _6462_/A VGND VGND VPWR VPWR _6462_/Y sky130_fd_sc_hd__inv_2
X_3674_ _6806_/Q VGND VGND VPWR VPWR _3674_/Y sky130_fd_sc_hd__inv_2
XFILLER_9_393 VGND VGND VPWR VPWR sky130_fd_sc_hd__fill_1
X_6393_ _6651_/A VGND VGND VPWR VPWR _6393_/Y sky130_fd_sc_hd__inv_2
X_5413_ _5413_/A0 _5107_/X _5429_/S VGND VGND VPWR VPWR _7127_/D sky130_fd_sc_hd__mux2_2
X_5344_ _5344_/A0 _5107_/X _5354_/S VGND VGND VPWR VPWR _7159_/D sky130_fd_sc_hd__mux2_2
XFILLER_102_604 VGND VGND VPWR VPWR sky130_fd_sc_hd__decap_3
XFILLER_114_442 VGND VGND VPWR VPWR sky130_fd_sc_hd__decap_3
XTAP_TAPCELL_ROW_93_1364 VGND VPWR sky130_fd_sc_hd__tapvpwrvgnd_1
XFILLER_99_142 VGND VGND VPWR VPWR sky130_fd_sc_hd__fill_1
XFILLER_102_637 VGND VGND VPWR VPWR sky130_fd_sc_hd__decap_3
XFILLER_114_475 VGND VGND VPWR VPWR sky130_fd_sc_hd__fill_1
XFILLER_114_486 VGND VGND VPWR VPWR sky130_fd_sc_hd__decap_3
XFILLER_99_175 VGND VGND VPWR VPWR sky130_fd_sc_hd__fill_2
XFILLER_99_164 VGND VGND VPWR VPWR sky130_fd_sc_hd__decap_3
XFILLER_102_648 VGND VGND VPWR VPWR sky130_fd_sc_hd__decap_3
XFILLER_87_337 VGND VGND VPWR VPWR sky130_fd_sc_hd__decap_3
X_7014_ _7322_/CLK _7014_/D _6294_/Y VGND VGND VPWR VPWR _7014_/Q sky130_fd_sc_hd__dfrtp_2
X_4226_ _4372_/A _4627_/A VGND VGND VPWR VPWR _4620_/A sky130_fd_sc_hd__nor2_2
XFILLER_101_169 VGND VGND VPWR VPWR sky130_fd_sc_hd__decap_3
XFILLER_68_562 VGND VGND VPWR VPWR sky130_fd_sc_hd__decap_3
X_4157_ _4157_/A _4205_/C VGND VGND VPWR VPWR _4158_/B sky130_fd_sc_hd__nand2_2
XFILLER_110_681 VGND VGND VPWR VPWR sky130_fd_sc_hd__decap_3
XFILLER_55_223 VGND VGND VPWR VPWR sky130_fd_sc_hd__fill_1
XFILLER_68_595 VGND VGND VPWR VPWR sky130_fd_sc_hd__decap_3
XFILLER_83_532 VGND VGND VPWR VPWR sky130_fd_sc_hd__decap_3
XFILLER_55_267 VGND VGND VPWR VPWR sky130_fd_sc_hd__decap_3
XFILLER_83_576 VGND VGND VPWR VPWR sky130_fd_sc_hd__decap_3
X_4088_ _7238_/Q _4433_/B _4491_/S _7051_/Q VGND VGND VPWR VPWR _4088_/X sky130_fd_sc_hd__a22o_2
XTAP_TAPCELL_ROW_54_903 VGND VPWR sky130_fd_sc_hd__tapvpwrvgnd_1
XFILLER_102_23 VGND VGND VPWR VPWR sky130_fd_sc_hd__fill_2
XFILLER_24_610 VGND VGND VPWR VPWR sky130_fd_sc_hd__decap_3
XFILLER_70_226 VGND VGND VPWR VPWR sky130_fd_sc_hd__decap_3
XFILLER_24_643 VGND VGND VPWR VPWR sky130_fd_sc_hd__fill_1
XFILLER_24_654 VGND VGND VPWR VPWR sky130_fd_sc_hd__decap_3
XFILLER_62_27 VGND VGND VPWR VPWR sky130_fd_sc_hd__fill_1
XFILLER_24_687 VGND VGND VPWR VPWR sky130_fd_sc_hd__decap_3
XFILLER_62_38 VGND VGND VPWR VPWR sky130_fd_sc_hd__decap_3
XTAP_TAPCELL_ROW_34_660 VGND VPWR sky130_fd_sc_hd__tapvpwrvgnd_1
XFILLER_11_337 VGND VGND VPWR VPWR sky130_fd_sc_hd__decap_3
XTAP_TAPCELL_ROW_62_991 VGND VPWR sky130_fd_sc_hd__tapvpwrvgnd_1
XTAP_TAPCELL_ROW_102_1471 VGND VPWR sky130_fd_sc_hd__tapvpwrvgnd_1
X_6729_ clkload6/A _6729_/D VGND VGND VPWR VPWR _6729_/Q sky130_fd_sc_hd__dfxtp_2
XFILLER_109_225 VGND VGND VPWR VPWR sky130_fd_sc_hd__decap_3
XFILLER_3_514 VGND VGND VPWR VPWR sky130_fd_sc_hd__decap_3
XFILLER_105_453 VGND VGND VPWR VPWR sky130_fd_sc_hd__decap_3
XFILLER_11_86 VGND VGND VPWR VPWR sky130_fd_sc_hd__fill_1
XFILLER_3_547 VGND VGND VPWR VPWR sky130_fd_sc_hd__decap_3
XFILLER_105_486 VGND VGND VPWR VPWR sky130_fd_sc_hd__decap_3
XFILLER_78_315 VGND VGND VPWR VPWR sky130_fd_sc_hd__decap_3
XFILLER_87_57 VGND VGND VPWR VPWR sky130_fd_sc_hd__decap_3
XFILLER_59_573 VGND VGND VPWR VPWR sky130_fd_sc_hd__decap_3
XFILLER_100_191 VGND VGND VPWR VPWR sky130_fd_sc_hd__fill_2
XFILLER_46_234 VGND VGND VPWR VPWR sky130_fd_sc_hd__decap_3
XFILLER_74_554 VGND VGND VPWR VPWR sky130_fd_sc_hd__decap_3
XFILLER_34_418 VGND VGND VPWR VPWR sky130_fd_sc_hd__fill_2
XFILLER_34_429 VGND VGND VPWR VPWR sky130_fd_sc_hd__decap_3
XFILLER_46_278 VGND VGND VPWR VPWR sky130_fd_sc_hd__decap_3
XFILLER_74_587 VGND VGND VPWR VPWR sky130_fd_sc_hd__fill_1
XFILLER_74_598 VGND VGND VPWR VPWR sky130_fd_sc_hd__decap_3
XFILLER_14_131 VGND VGND VPWR VPWR sky130_fd_sc_hd__fill_1
XFILLER_15_632 VGND VGND VPWR VPWR sky130_fd_sc_hd__decap_3
XFILLER_15_665 VGND VGND VPWR VPWR sky130_fd_sc_hd__decap_3
XFILLER_15_676 VGND VGND VPWR VPWR sky130_fd_sc_hd__decap_3
XFILLER_30_613 VGND VGND VPWR VPWR sky130_fd_sc_hd__decap_3
XFILLER_14_197 VGND VGND VPWR VPWR sky130_fd_sc_hd__decap_3
XFILLER_30_657 VGND VGND VPWR VPWR sky130_fd_sc_hd__decap_3
XFILLER_6_352 VGND VGND VPWR VPWR sky130_fd_sc_hd__decap_3
Xhold809 _6805_/Q VGND VGND VPWR VPWR _6805_/D sky130_fd_sc_hd__dlygate4sd3_1
XTAP_TAPCELL_ROW_12_398 VGND VPWR sky130_fd_sc_hd__tapvpwrvgnd_1
X_3390_ _7155_/Q _3366_/X _3379_/X _3389_/X VGND VGND VPWR VPWR _3390_/X sky130_fd_sc_hd__a211o_2
XFILLER_69_315 VGND VGND VPWR VPWR sky130_fd_sc_hd__decap_3
XFILLER_97_635 VGND VGND VPWR VPWR sky130_fd_sc_hd__decap_3
XFILLER_111_423 VGND VGND VPWR VPWR sky130_fd_sc_hd__decap_3
XFILLER_69_337 VGND VGND VPWR VPWR sky130_fd_sc_hd__decap_3
XFILLER_96_123 VGND VGND VPWR VPWR sky130_fd_sc_hd__decap_3
X_5060_ _5593_/B _5045_/X _5059_/X _4467_/B VGND VGND VPWR VPWR _5060_/X sky130_fd_sc_hd__a22o_2
XFILLER_97_668 VGND VGND VPWR VPWR sky130_fd_sc_hd__decap_3
XFILLER_111_467 VGND VGND VPWR VPWR sky130_fd_sc_hd__decap_3
XFILLER_96_156 VGND VGND VPWR VPWR sky130_fd_sc_hd__decap_3
X_4011_ _7342_/Q _3947_/S _4406_/A2 _7374_/Q _4429_/C1 VGND VGND VPWR VPWR _4011_/X
+ sky130_fd_sc_hd__a221o_2
XFILLER_97_679 VGND VGND VPWR VPWR sky130_fd_sc_hd__decap_3
XFILLER_96_189 VGND VGND VPWR VPWR sky130_fd_sc_hd__decap_3
XFILLER_37_256 VGND VGND VPWR VPWR sky130_fd_sc_hd__decap_3
XFILLER_65_576 VGND VGND VPWR VPWR sky130_fd_sc_hd__decap_3
XFILLER_80_557 VGND VGND VPWR VPWR sky130_fd_sc_hd__decap_3
X_4913_ _4907_/Y _3762_/X _4910_/Y _6997_/D _5040_/S VGND VGND VPWR VPWR _4913_/X
+ sky130_fd_sc_hd__o32a_2
XFILLER_21_635 VGND VGND VPWR VPWR sky130_fd_sc_hd__decap_3
X_4844_ _4633_/A _4111_/B _4842_/X _4843_/Y _4948_/A VGND VGND VPWR VPWR _4855_/A
+ sky130_fd_sc_hd__a311oi_2
XFILLER_21_668 VGND VGND VPWR VPWR sky130_fd_sc_hd__decap_3
XFILLER_21_679 VGND VGND VPWR VPWR sky130_fd_sc_hd__decap_3
X_4775_ _4775_/A _4775_/B VGND VGND VPWR VPWR _7004_/D sky130_fd_sc_hd__nor2_2
X_6514_ _6610_/A VGND VGND VPWR VPWR _6514_/Y sky130_fd_sc_hd__inv_2
X_3726_ _3714_/X _3721_/X _3724_/X _3725_/X VGND VGND VPWR VPWR _3726_/X sky130_fd_sc_hd__a22o_2
X_6445_ _6638_/A VGND VGND VPWR VPWR _6445_/Y sky130_fd_sc_hd__inv_2
X_6376_ _6571_/A VGND VGND VPWR VPWR _6376_/Y sky130_fd_sc_hd__inv_2
XFILLER_102_401 VGND VGND VPWR VPWR sky130_fd_sc_hd__fill_1
XFILLER_88_613 VGND VGND VPWR VPWR sky130_fd_sc_hd__decap_3
X_5327_ _5327_/A0 _4978_/X _5340_/S VGND VGND VPWR VPWR _7167_/D sky130_fd_sc_hd__mux2_2
XFILLER_87_145 VGND VGND VPWR VPWR sky130_fd_sc_hd__decap_3
XFILLER_88_657 VGND VGND VPWR VPWR sky130_fd_sc_hd__decap_3
XFILLER_102_456 VGND VGND VPWR VPWR sky130_fd_sc_hd__fill_2
XFILLER_87_167 VGND VGND VPWR VPWR sky130_fd_sc_hd__fill_1
X_5258_ _5258_/A0 _4945_/X _5262_/S VGND VGND VPWR VPWR _7201_/D sky130_fd_sc_hd__mux2_2
XFILLER_102_489 VGND VGND VPWR VPWR sky130_fd_sc_hd__decap_3
XFILLER_113_11 VGND VGND VPWR VPWR sky130_fd_sc_hd__decap_3
XFILLER_96_690 VGND VGND VPWR VPWR sky130_fd_sc_hd__fill_1
X_4209_ _4633_/A _4903_/A _4845_/A _4890_/B VGND VGND VPWR VPWR _4384_/A sky130_fd_sc_hd__and4_2
XFILLER_113_44 VGND VGND VPWR VPWR sky130_fd_sc_hd__decap_3
XFILLER_28_256 VGND VGND VPWR VPWR sky130_fd_sc_hd__decap_3
XFILLER_83_340 VGND VGND VPWR VPWR sky130_fd_sc_hd__decap_3
XFILLER_113_66 VGND VGND VPWR VPWR sky130_fd_sc_hd__decap_3
XFILLER_16_429 VGND VGND VPWR VPWR sky130_fd_sc_hd__decap_3
XFILLER_28_278 VGND VGND VPWR VPWR sky130_fd_sc_hd__decap_3
XFILLER_43_215 VGND VGND VPWR VPWR sky130_fd_sc_hd__decap_3
XFILLER_56_576 VGND VGND VPWR VPWR sky130_fd_sc_hd__decap_3
XFILLER_56_598 VGND VGND VPWR VPWR sky130_fd_sc_hd__decap_3
XFILLER_73_26 VGND VGND VPWR VPWR sky130_fd_sc_hd__decap_3
XFILLER_83_384 VGND VGND VPWR VPWR sky130_fd_sc_hd__decap_3
XTAP_TAPCELL_ROW_104_1500 VGND VPWR sky130_fd_sc_hd__tapvpwrvgnd_1
XFILLER_43_248 VGND VGND VPWR VPWR sky130_fd_sc_hd__decap_3
XFILLER_71_546 VGND VGND VPWR VPWR sky130_fd_sc_hd__decap_3
XFILLER_12_613 VGND VGND VPWR VPWR sky130_fd_sc_hd__decap_3
XFILLER_24_440 VGND VGND VPWR VPWR sky130_fd_sc_hd__decap_3
XFILLER_71_579 VGND VGND VPWR VPWR sky130_fd_sc_hd__decap_3
XFILLER_12_657 VGND VGND VPWR VPWR sky130_fd_sc_hd__decap_3
XFILLER_51_292 VGND VGND VPWR VPWR sky130_fd_sc_hd__decap_3
XFILLER_8_628 VGND VGND VPWR VPWR sky130_fd_sc_hd__decap_3
XPHY_EDGE_ROW_91_Left_208 VGND VGND VPWR VPWR sky130_fd_sc_hd__decap_3
XFILLER_20_690 VGND VGND VPWR VPWR sky130_fd_sc_hd__fill_1
XFILLER_3_300 VGND VGND VPWR VPWR sky130_fd_sc_hd__decap_3
XFILLER_98_12 VGND VGND VPWR VPWR sky130_fd_sc_hd__decap_3
XFILLER_105_272 VGND VGND VPWR VPWR sky130_fd_sc_hd__decap_3
XFILLER_79_635 VGND VGND VPWR VPWR sky130_fd_sc_hd__decap_3
XFILLER_79_668 VGND VGND VPWR VPWR sky130_fd_sc_hd__decap_3
XFILLER_66_318 VGND VGND VPWR VPWR sky130_fd_sc_hd__decap_3
XFILLER_79_679 VGND VGND VPWR VPWR sky130_fd_sc_hd__decap_3
XFILLER_94_616 VGND VGND VPWR VPWR sky130_fd_sc_hd__decap_3
XFILLER_19_201 VGND VGND VPWR VPWR sky130_fd_sc_hd__fill_2
XFILLER_19_223 VGND VGND VPWR VPWR sky130_fd_sc_hd__fill_1
XFILLER_66_329 VGND VGND VPWR VPWR sky130_fd_sc_hd__decap_3
XFILLER_74_351 VGND VGND VPWR VPWR sky130_fd_sc_hd__fill_2
XFILLER_34_204 VGND VGND VPWR VPWR sky130_fd_sc_hd__fill_2
XFILLER_47_576 VGND VGND VPWR VPWR sky130_fd_sc_hd__decap_3
XFILLER_62_557 VGND VGND VPWR VPWR sky130_fd_sc_hd__decap_3
XTAP_TAPCELL_ROW_66_1049 VGND VPWR sky130_fd_sc_hd__tapvpwrvgnd_1
XTAP_TAPCELL_ROW_66_1038 VGND VPWR sky130_fd_sc_hd__tapvpwrvgnd_1
XTAP_TAPCELL_ROW_45_788 VGND VPWR sky130_fd_sc_hd__tapvpwrvgnd_1
XTAP_TAPCELL_ROW_17_457 VGND VPWR sky130_fd_sc_hd__tapvpwrvgnd_1
XFILLER_30_421 VGND VGND VPWR VPWR sky130_fd_sc_hd__fill_1
XFILLER_42_270 VGND VGND VPWR VPWR sky130_fd_sc_hd__decap_3
XFILLER_63_81 VGND VGND VPWR VPWR sky130_fd_sc_hd__decap_3
XFILLER_30_454 VGND VGND VPWR VPWR sky130_fd_sc_hd__fill_2
XFILLER_7_650 VGND VGND VPWR VPWR sky130_fd_sc_hd__decap_3
Xhold606 _6963_/Q VGND VGND VPWR VPWR _6963_/D sky130_fd_sc_hd__dlygate4sd3_1
Xhold617 _6837_/Q VGND VGND VPWR VPWR _6837_/D sky130_fd_sc_hd__dlygate4sd3_1
X_4491_ _7334_/Q _7302_/Q _4491_/S VGND VGND VPWR VPWR _7334_/D sky130_fd_sc_hd__mux2_2
Xhold628 _6899_/Q VGND VGND VPWR VPWR _6899_/D sky130_fd_sc_hd__dlygate4sd3_1
Xhold639 _6820_/Q VGND VGND VPWR VPWR _6820_/D sky130_fd_sc_hd__dlygate4sd3_1
X_3442_ _3874_/A _3442_/B VGND VGND VPWR VPWR _4394_/A sky130_fd_sc_hd__nand2_2
XTAP_TAPCELL_ROW_77_1178 VGND VPWR sky130_fd_sc_hd__tapvpwrvgnd_1
X_3373_ _3560_/B _3370_/Y _4471_/S VGND VGND VPWR VPWR _3429_/A sky130_fd_sc_hd__a21o_2
XFILLER_69_134 VGND VGND VPWR VPWR sky130_fd_sc_hd__decap_3
XFILLER_97_421 VGND VGND VPWR VPWR sky130_fd_sc_hd__decap_3
X_5112_ _4292_/A _3594_/B _4295_/X VGND VGND VPWR VPWR _5113_/B sky130_fd_sc_hd__a21oi_2
XTAP_TAPCELL_ROW_90_1334 VGND VPWR sky130_fd_sc_hd__tapvpwrvgnd_1
XFILLER_97_476 VGND VGND VPWR VPWR sky130_fd_sc_hd__decap_3
XFILLER_111_275 VGND VGND VPWR VPWR sky130_fd_sc_hd__decap_3
XFILLER_38_521 VGND VGND VPWR VPWR sky130_fd_sc_hd__fill_2
XFILLER_69_178 VGND VGND VPWR VPWR sky130_fd_sc_hd__fill_1
XFILLER_78_690 VGND VGND VPWR VPWR sky130_fd_sc_hd__fill_1
XFILLER_84_126 VGND VGND VPWR VPWR sky130_fd_sc_hd__decap_3
XFILLER_85_638 VGND VGND VPWR VPWR sky130_fd_sc_hd__decap_3
X_5043_ _6988_/Q _5066_/A VGND VGND VPWR VPWR _5044_/B sky130_fd_sc_hd__nor2_2
XFILLER_38_554 VGND VGND VPWR VPWR sky130_fd_sc_hd__decap_3
XFILLER_38_587 VGND VGND VPWR VPWR sky130_fd_sc_hd__fill_1
XFILLER_38_598 VGND VGND VPWR VPWR sky130_fd_sc_hd__decap_3
XFILLER_93_671 VGND VGND VPWR VPWR sky130_fd_sc_hd__fill_1
XFILLER_93_682 VGND VGND VPWR VPWR sky130_fd_sc_hd__decap_3
XFILLER_25_237 VGND VGND VPWR VPWR sky130_fd_sc_hd__decap_3
X_6994_ _7144_/CLK _6994_/D _6274_/Y VGND VGND VPWR VPWR _6994_/Q sky130_fd_sc_hd__dfrtp_2
XFILLER_53_579 VGND VGND VPWR VPWR sky130_fd_sc_hd__decap_3
XFILLER_80_365 VGND VGND VPWR VPWR sky130_fd_sc_hd__decap_3
XFILLER_33_270 VGND VGND VPWR VPWR sky130_fd_sc_hd__decap_3
XFILLER_33_281 VGND VGND VPWR VPWR sky130_fd_sc_hd__decap_3
XFILLER_40_218 VGND VGND VPWR VPWR sky130_fd_sc_hd__decap_3
X_4827_ _4827_/A _4827_/B VGND VGND VPWR VPWR _4827_/X sky130_fd_sc_hd__xor2_2
XFILLER_5_609 VGND VGND VPWR VPWR sky130_fd_sc_hd__decap_3
X_4758_ _7004_/Q _4804_/A VGND VGND VPWR VPWR _4777_/B sky130_fd_sc_hd__nand2_2
XFILLER_107_526 VGND VGND VPWR VPWR sky130_fd_sc_hd__decap_3
X_4689_ _7002_/Q _4834_/A _4688_/X _7003_/Q VGND VGND VPWR VPWR _4804_/A sky130_fd_sc_hd__o211a_2
X_3709_ _3682_/A _3708_/X _4791_/A1 VGND VGND VPWR VPWR _3709_/X sky130_fd_sc_hd__a21o_2
XFILLER_107_559 VGND VGND VPWR VPWR sky130_fd_sc_hd__fill_1
XFILLER_108_44 VGND VGND VPWR VPWR sky130_fd_sc_hd__decap_3
X_6428_ _6494_/A VGND VGND VPWR VPWR _6428_/Y sky130_fd_sc_hd__inv_2
XFILLER_108_77 VGND VGND VPWR VPWR sky130_fd_sc_hd__decap_3
XFILLER_115_570 VGND VGND VPWR VPWR sky130_fd_sc_hd__decap_3
XFILLER_68_15 VGND VGND VPWR VPWR sky130_fd_sc_hd__decap_3
XFILLER_88_410 VGND VGND VPWR VPWR sky130_fd_sc_hd__fill_1
XFILLER_68_59 VGND VGND VPWR VPWR sky130_fd_sc_hd__decap_3
XFILLER_88_421 VGND VGND VPWR VPWR sky130_fd_sc_hd__decap_3
X_6359_ _6364_/A VGND VGND VPWR VPWR _6359_/Y sky130_fd_sc_hd__inv_2
XFILLER_102_253 VGND VGND VPWR VPWR sky130_fd_sc_hd__fill_1
XFILLER_76_616 VGND VGND VPWR VPWR sky130_fd_sc_hd__decap_3
XFILLER_88_465 VGND VGND VPWR VPWR sky130_fd_sc_hd__fill_2
XFILLER_102_275 VGND VGND VPWR VPWR sky130_fd_sc_hd__decap_3
XFILLER_102_297 VGND VGND VPWR VPWR sky130_fd_sc_hd__fill_1
XFILLER_75_126 VGND VGND VPWR VPWR sky130_fd_sc_hd__decap_3
XTAP_TAPCELL_ROW_110_1570 VGND VPWR sky130_fd_sc_hd__tapvpwrvgnd_1
XFILLER_29_554 VGND VGND VPWR VPWR sky130_fd_sc_hd__decap_3
XFILLER_75_137 VGND VGND VPWR VPWR sky130_fd_sc_hd__decap_3
XFILLER_29_576 VGND VGND VPWR VPWR sky130_fd_sc_hd__decap_3
XFILLER_56_362 VGND VGND VPWR VPWR sky130_fd_sc_hd__fill_2
XFILLER_84_660 VGND VGND VPWR VPWR sky130_fd_sc_hd__decap_3
XFILLER_90_107 VGND VGND VPWR VPWR sky130_fd_sc_hd__decap_3
XFILLER_16_237 VGND VGND VPWR VPWR sky130_fd_sc_hd__decap_3
XFILLER_17_74 VGND VGND VPWR VPWR sky130_fd_sc_hd__decap_3
XFILLER_44_557 VGND VGND VPWR VPWR sky130_fd_sc_hd__decap_3
XFILLER_56_395 VGND VGND VPWR VPWR sky130_fd_sc_hd__decap_3
XFILLER_71_310 VGND VGND VPWR VPWR sky130_fd_sc_hd__decap_3
XFILLER_71_343 VGND VGND VPWR VPWR sky130_fd_sc_hd__fill_2
XFILLER_16_259 VGND VGND VPWR VPWR sky130_fd_sc_hd__decap_3
XFILLER_17_96 VGND VGND VPWR VPWR sky130_fd_sc_hd__fill_1
XTAP_TAPCELL_ROW_14_416 VGND VPWR sky130_fd_sc_hd__tapvpwrvgnd_1
XFILLER_24_292 VGND VGND VPWR VPWR sky130_fd_sc_hd__decap_3
XTAP_TAPCELL_ROW_42_758 VGND VPWR sky130_fd_sc_hd__tapvpwrvgnd_1
XFILLER_8_469 VGND VGND VPWR VPWR sky130_fd_sc_hd__fill_1
XFILLER_4_631 VGND VGND VPWR VPWR sky130_fd_sc_hd__decap_3
XFILLER_113_529 VGND VGND VPWR VPWR sky130_fd_sc_hd__decap_3
XFILLER_3_163 VGND VGND VPWR VPWR sky130_fd_sc_hd__decap_3
XFILLER_4_675 VGND VGND VPWR VPWR sky130_fd_sc_hd__decap_3
XFILLER_98_218 VGND VGND VPWR VPWR sky130_fd_sc_hd__decap_3
XFILLER_106_581 VGND VGND VPWR VPWR sky130_fd_sc_hd__decap_3
XFILLER_106_592 VGND VGND VPWR VPWR sky130_fd_sc_hd__decap_3
XFILLER_79_443 VGND VGND VPWR VPWR sky130_fd_sc_hd__decap_3
XFILLER_67_638 VGND VGND VPWR VPWR sky130_fd_sc_hd__decap_3
XFILLER_94_435 VGND VGND VPWR VPWR sky130_fd_sc_hd__fill_2
XFILLER_47_340 VGND VGND VPWR VPWR sky130_fd_sc_hd__decap_3
XFILLER_66_137 VGND VGND VPWR VPWR sky130_fd_sc_hd__decap_3
XFILLER_82_619 VGND VGND VPWR VPWR sky130_fd_sc_hd__decap_3
XFILLER_47_373 VGND VGND VPWR VPWR sky130_fd_sc_hd__decap_3
XFILLER_75_671 VGND VGND VPWR VPWR sky130_fd_sc_hd__fill_1
XFILLER_75_682 VGND VGND VPWR VPWR sky130_fd_sc_hd__decap_3
XFILLER_81_107 VGND VGND VPWR VPWR sky130_fd_sc_hd__decap_3
XFILLER_35_557 VGND VGND VPWR VPWR sky130_fd_sc_hd__decap_3
XFILLER_62_321 VGND VGND VPWR VPWR sky130_fd_sc_hd__fill_1
XFILLER_74_192 VGND VGND VPWR VPWR sky130_fd_sc_hd__decap_3
XFILLER_35_579 VGND VGND VPWR VPWR sky130_fd_sc_hd__decap_3
XFILLER_74_91 VGND VGND VPWR VPWR sky130_fd_sc_hd__fill_2
XFILLER_90_663 VGND VGND VPWR VPWR sky130_fd_sc_hd__decap_3
X_3991_ _3991_/A _3991_/B VGND VGND VPWR VPWR _3991_/X sky130_fd_sc_hd__or2_2
XFILLER_22_229 VGND VGND VPWR VPWR sky130_fd_sc_hd__decap_3
XFILLER_15_281 VGND VGND VPWR VPWR sky130_fd_sc_hd__fill_1
XFILLER_30_262 VGND VGND VPWR VPWR sky130_fd_sc_hd__decap_3
X_7400_ _7406_/CLK _7400_/D _6680_/Y VGND VGND VPWR VPWR _7400_/Q sky130_fd_sc_hd__dfrtp_2
X_5661_ _5661_/A _5661_/B _5661_/C _5661_/D VGND VGND VPWR VPWR _5661_/X sky130_fd_sc_hd__and4_2
X_4612_ _4612_/A _4612_/B VGND VGND VPWR VPWR _5114_/B sky130_fd_sc_hd__nor2_2
XFILLER_116_301 VGND VGND VPWR VPWR sky130_fd_sc_hd__decap_3
XFILLER_116_312 VGND VGND VPWR VPWR sky130_fd_sc_hd__decap_3
X_7331_ _7365_/CLK _7331_/D _6611_/Y VGND VGND VPWR VPWR _7331_/Q sky130_fd_sc_hd__dfrtp_2
XFILLER_116_323 VGND VGND VPWR VPWR sky130_fd_sc_hd__decap_3
XFILLER_116_345 VGND VGND VPWR VPWR sky130_fd_sc_hd__decap_3
X_7262_ _7364_/CLK _7262_/D _6542_/Y VGND VGND VPWR VPWR _7262_/Q sky130_fd_sc_hd__dfrtp_2
XFILLER_104_507 VGND VGND VPWR VPWR sky130_fd_sc_hd__decap_3
XFILLER_116_389 VGND VGND VPWR VPWR sky130_fd_sc_hd__decap_3
XFILLER_89_207 VGND VGND VPWR VPWR sky130_fd_sc_hd__decap_3
X_4474_ _4474_/A0 _4540_/A _4478_/S VGND VGND VPWR VPWR _7342_/D sky130_fd_sc_hd__mux2_2
X_7193_ _7322_/CLK _7193_/D _6473_/Y VGND VGND VPWR VPWR _7193_/Q sky130_fd_sc_hd__dfrtp_2
X_3425_ _3589_/A _4376_/A _3589_/B _3590_/C VGND VGND VPWR VPWR _3527_/A sky130_fd_sc_hd__o31a_2
XFILLER_112_551 VGND VGND VPWR VPWR sky130_fd_sc_hd__decap_3
XFILLER_58_616 VGND VGND VPWR VPWR sky130_fd_sc_hd__decap_3
X_3356_ _5118_/D _3354_/X _3355_/Y _5129_/A VGND VGND VPWR VPWR _4537_/B sky130_fd_sc_hd__a22o_2
XFILLER_112_584 VGND VGND VPWR VPWR sky130_fd_sc_hd__decap_3
XFILLER_112_595 VGND VGND VPWR VPWR sky130_fd_sc_hd__decap_3
XFILLER_38_29 VGND VGND VPWR VPWR sky130_fd_sc_hd__fill_2
XFILLER_85_435 VGND VGND VPWR VPWR sky130_fd_sc_hd__decap_3
XFILLER_97_273 VGND VGND VPWR VPWR sky130_fd_sc_hd__decap_3
XFILLER_97_284 VGND VGND VPWR VPWR sky130_fd_sc_hd__decap_3
Xhold1103 _7283_/Q VGND VGND VPWR VPWR _4595_/A sky130_fd_sc_hd__dlygate4sd3_1
Xhold1114 _7225_/Q VGND VGND VPWR VPWR _5207_/A sky130_fd_sc_hd__dlygate4sd3_1
XFILLER_57_148 VGND VGND VPWR VPWR sky130_fd_sc_hd__fill_2
XFILLER_85_457 VGND VGND VPWR VPWR sky130_fd_sc_hd__fill_1
Xhold1125 _7129_/Q VGND VGND VPWR VPWR _5409_/A0 sky130_fd_sc_hd__dlygate4sd3_1
Xhold1136 _7232_/Q VGND VGND VPWR VPWR _5192_/A sky130_fd_sc_hd__dlygate4sd3_1
Xhold1147 _7125_/Q VGND VGND VPWR VPWR _5417_/A0 sky130_fd_sc_hd__dlygate4sd3_1
Xhold1158 _7131_/Q VGND VGND VPWR VPWR _5404_/A0 sky130_fd_sc_hd__dlygate4sd3_1
X_5026_ _5026_/A _5026_/B VGND VGND VPWR VPWR _6990_/D sky130_fd_sc_hd__nor2_2
XFILLER_38_351 VGND VGND VPWR VPWR sky130_fd_sc_hd__decap_3
XFILLER_66_660 VGND VGND VPWR VPWR sky130_fd_sc_hd__decap_3
XFILLER_85_479 VGND VGND VPWR VPWR sky130_fd_sc_hd__decap_3
Xhold1169 _7228_/Q VGND VGND VPWR VPWR _5200_/A sky130_fd_sc_hd__dlygate4sd3_1
XFILLER_65_181 VGND VGND VPWR VPWR sky130_fd_sc_hd__decap_3
XFILLER_81_641 VGND VGND VPWR VPWR sky130_fd_sc_hd__decap_3
XFILLER_26_568 VGND VGND VPWR VPWR sky130_fd_sc_hd__decap_3
XFILLER_53_343 VGND VGND VPWR VPWR sky130_fd_sc_hd__decap_3
X_6977_ clkload8/A _6977_/D VGND VGND VPWR VPWR _6977_/Q sky130_fd_sc_hd__dfxtp_2
XFILLER_110_12 VGND VGND VPWR VPWR sky130_fd_sc_hd__decap_3
XFILLER_80_162 VGND VGND VPWR VPWR sky130_fd_sc_hd__decap_3
XFILLER_81_685 VGND VGND VPWR VPWR sky130_fd_sc_hd__decap_3
XFILLER_110_56 VGND VGND VPWR VPWR sky130_fd_sc_hd__decap_3
XFILLER_80_195 VGND VGND VPWR VPWR sky130_fd_sc_hd__fill_1
XFILLER_21_240 VGND VGND VPWR VPWR sky130_fd_sc_hd__fill_2
XFILLER_21_295 VGND VGND VPWR VPWR sky130_fd_sc_hd__decap_3
XFILLER_107_312 VGND VGND VPWR VPWR sky130_fd_sc_hd__fill_1
XFILLER_1_601 VGND VGND VPWR VPWR sky130_fd_sc_hd__decap_3
XFILLER_1_623 VGND VGND VPWR VPWR sky130_fd_sc_hd__decap_3
Xhold981 _7399_/Q VGND VGND VPWR VPWR hold981/X sky130_fd_sc_hd__dlygate4sd3_1
Xhold970 _7054_/Q VGND VGND VPWR VPWR hold970/X sky130_fd_sc_hd__dlygate4sd3_1
XFILLER_0_144 VGND VGND VPWR VPWR sky130_fd_sc_hd__fill_1
XFILLER_1_656 VGND VGND VPWR VPWR sky130_fd_sc_hd__fill_2
XFILLER_88_251 VGND VGND VPWR VPWR sky130_fd_sc_hd__fill_1
Xhold992 _7051_/Q VGND VGND VPWR VPWR hold992/X sky130_fd_sc_hd__dlygate4sd3_1
XFILLER_0_177 VGND VGND VPWR VPWR sky130_fd_sc_hd__decap_3
XFILLER_103_573 VGND VGND VPWR VPWR sky130_fd_sc_hd__decap_3
XFILLER_49_638 VGND VGND VPWR VPWR sky130_fd_sc_hd__decap_3
XFILLER_88_262 VGND VGND VPWR VPWR sky130_fd_sc_hd__decap_3
XFILLER_88_284 VGND VGND VPWR VPWR sky130_fd_sc_hd__decap_3
XFILLER_95_57 VGND VGND VPWR VPWR sky130_fd_sc_hd__decap_3
XFILLER_95_68 VGND VGND VPWR VPWR sky130_fd_sc_hd__decap_3
XFILLER_17_502 VGND VGND VPWR VPWR sky130_fd_sc_hd__fill_2
XFILLER_29_340 VGND VGND VPWR VPWR sky130_fd_sc_hd__decap_3
XFILLER_57_671 VGND VGND VPWR VPWR sky130_fd_sc_hd__fill_1
XFILLER_57_682 VGND VGND VPWR VPWR sky130_fd_sc_hd__decap_3
XFILLER_64_619 VGND VGND VPWR VPWR sky130_fd_sc_hd__decap_3
XTAP_TAPCELL_ROW_47_817 VGND VPWR sky130_fd_sc_hd__tapvpwrvgnd_1
XFILLER_17_535 VGND VGND VPWR VPWR sky130_fd_sc_hd__decap_3
XFILLER_56_192 VGND VGND VPWR VPWR sky130_fd_sc_hd__decap_3
XFILLER_91_438 VGND VGND VPWR VPWR sky130_fd_sc_hd__fill_1
XFILLER_91_449 VGND VGND VPWR VPWR sky130_fd_sc_hd__fill_1
XFILLER_17_579 VGND VGND VPWR VPWR sky130_fd_sc_hd__decap_3
XFILLER_44_343 VGND VGND VPWR VPWR sky130_fd_sc_hd__decap_3
XFILLER_71_140 VGND VGND VPWR VPWR sky130_fd_sc_hd__decap_3
XFILLER_72_663 VGND VGND VPWR VPWR sky130_fd_sc_hd__decap_3
XTAP_TAPCELL_ROW_63_1008 VGND VPWR sky130_fd_sc_hd__tapvpwrvgnd_1
XTAP_TAPCELL_ROW_27_574 VGND VPWR sky130_fd_sc_hd__tapvpwrvgnd_1
XFILLER_71_195 VGND VGND VPWR VPWR sky130_fd_sc_hd__fill_1
XFILLER_12_251 VGND VGND VPWR VPWR sky130_fd_sc_hd__fill_1
XFILLER_12_262 VGND VGND VPWR VPWR sky130_fd_sc_hd__decap_3
XFILLER_40_560 VGND VGND VPWR VPWR sky130_fd_sc_hd__decap_3
XFILLER_8_200 VGND VGND VPWR VPWR sky130_fd_sc_hd__decap_3
XFILLER_8_233 VGND VGND VPWR VPWR sky130_fd_sc_hd__decap_3
XFILLER_60_82 VGND VGND VPWR VPWR sky130_fd_sc_hd__fill_2
XFILLER_8_277 VGND VGND VPWR VPWR sky130_fd_sc_hd__decap_3
Xoutput508 _4671_/B VGND VGND VPWR VPWR instruction_out[28] sky130_fd_sc_hd__clkdlybuf4s25_1
Xoutput519 _6987_/Q VGND VGND VPWR VPWR pc_out[10] sky130_fd_sc_hd__clkdlybuf4s25_1
XTAP_TAPCELL_ROW_74_1137 VGND VPWR sky130_fd_sc_hd__tapvpwrvgnd_1
XFILLER_99_505 VGND VGND VPWR VPWR sky130_fd_sc_hd__decap_3
XFILLER_113_315 VGND VGND VPWR VPWR sky130_fd_sc_hd__fill_2
XFILLER_113_337 VGND VGND VPWR VPWR sky130_fd_sc_hd__decap_3
XFILLER_4_483 VGND VGND VPWR VPWR sky130_fd_sc_hd__decap_3
XFILLER_5_66 VGND VGND VPWR VPWR sky130_fd_sc_hd__decap_3
XFILLER_99_538 VGND VGND VPWR VPWR sky130_fd_sc_hd__decap_3
X_4190_ _7263_/Q _4422_/A2 _4420_/B1 _7135_/Q _4189_/X VGND VGND VPWR VPWR _4637_/B
+ sky130_fd_sc_hd__a221o_2
XFILLER_79_284 VGND VGND VPWR VPWR sky130_fd_sc_hd__decap_3
XFILLER_10_3 VGND VGND VPWR VPWR sky130_fd_sc_hd__decap_3
XFILLER_94_243 VGND VGND VPWR VPWR sky130_fd_sc_hd__fill_1
XFILLER_48_660 VGND VGND VPWR VPWR sky130_fd_sc_hd__decap_3
XFILLER_82_405 VGND VGND VPWR VPWR sky130_fd_sc_hd__fill_1
XFILLER_82_427 VGND VGND VPWR VPWR sky130_fd_sc_hd__decap_3
XFILLER_94_265 VGND VGND VPWR VPWR sky130_fd_sc_hd__decap_3
XFILLER_35_321 VGND VGND VPWR VPWR sky130_fd_sc_hd__decap_3
XFILLER_63_641 VGND VGND VPWR VPWR sky130_fd_sc_hd__decap_3
X_6900_ _6968_/CLK _6900_/D VGND VGND VPWR VPWR _6900_/Q sky130_fd_sc_hd__dfxtp_2
XFILLER_35_343 VGND VGND VPWR VPWR sky130_fd_sc_hd__decap_3
X_6831_ clkload6/A _6831_/D VGND VGND VPWR VPWR _6831_/Q sky130_fd_sc_hd__dfxtp_2
XTAP_TAPCELL_ROW_85_1266 VGND VPWR sky130_fd_sc_hd__tapvpwrvgnd_1
XFILLER_63_685 VGND VGND VPWR VPWR sky130_fd_sc_hd__decap_3
XTAP_TAPCELL_ROW_85_1277 VGND VPWR sky130_fd_sc_hd__tapvpwrvgnd_1
XFILLER_23_549 VGND VGND VPWR VPWR sky130_fd_sc_hd__decap_3
XFILLER_62_195 VGND VGND VPWR VPWR sky130_fd_sc_hd__fill_1
X_6762_ _6974_/CLK _6762_/D VGND VGND VPWR VPWR _6762_/Q sky130_fd_sc_hd__dfxtp_2
XFILLER_50_368 VGND VGND VPWR VPWR sky130_fd_sc_hd__decap_3
X_6693_ _6966_/CLK _6693_/D VGND VGND VPWR VPWR _6693_/Q sky130_fd_sc_hd__dfxtp_2
XFILLER_31_582 VGND VGND VPWR VPWR sky130_fd_sc_hd__decap_3
X_5644_ _3371_/A _5130_/C _3340_/B _6980_/Q VGND VGND VPWR VPWR _5644_/X sky130_fd_sc_hd__o211a_2
XFILLER_116_131 VGND VGND VPWR VPWR sky130_fd_sc_hd__decap_3
X_7314_ _7355_/CLK _7314_/D _6594_/Y VGND VGND VPWR VPWR _7314_/Q sky130_fd_sc_hd__dfrtp_2
X_5575_ hold944/X _5587_/B _5010_/D VGND VGND VPWR VPWR _7042_/D sky130_fd_sc_hd__a21o_2
XFILLER_104_304 VGND VGND VPWR VPWR sky130_fd_sc_hd__decap_3
XFILLER_2_409 VGND VGND VPWR VPWR sky130_fd_sc_hd__fill_1
X_4526_ _4526_/A0 _4593_/A _4528_/B VGND VGND VPWR VPWR _7316_/D sky130_fd_sc_hd__mux2_2
XFILLER_104_315 VGND VGND VPWR VPWR sky130_fd_sc_hd__decap_3
XFILLER_116_175 VGND VGND VPWR VPWR sky130_fd_sc_hd__decap_3
XFILLER_116_197 VGND VGND VPWR VPWR sky130_fd_sc_hd__decap_3
X_7245_ _7372_/CLK _7245_/D _6525_/Y VGND VGND VPWR VPWR _7245_/Q sky130_fd_sc_hd__dfrtp_2
X_4457_ _4720_/A _4720_/B _4456_/X VGND VGND VPWR VPWR _4457_/X sky130_fd_sc_hd__o21a_2
X_7176_ _7368_/CLK _7176_/D _6456_/Y VGND VGND VPWR VPWR _7176_/Q sky130_fd_sc_hd__dfrtp_2
XFILLER_98_560 VGND VGND VPWR VPWR sky130_fd_sc_hd__decap_3
XFILLER_100_510 VGND VGND VPWR VPWR sky130_fd_sc_hd__decap_3
XFILLER_105_12 VGND VGND VPWR VPWR sky130_fd_sc_hd__decap_3
XFILLER_58_424 VGND VGND VPWR VPWR sky130_fd_sc_hd__decap_3
X_4388_ _7273_/Q _4437_/A2 _4385_/X _4387_/X VGND VGND VPWR VPWR _4388_/X sky130_fd_sc_hd__a211o_2
XFILLER_100_554 VGND VGND VPWR VPWR sky130_fd_sc_hd__decap_3
XFILLER_105_45 VGND VGND VPWR VPWR sky130_fd_sc_hd__decap_3
XFILLER_58_435 VGND VGND VPWR VPWR sky130_fd_sc_hd__decap_3
X_3339_ _3319_/X _5238_/B _3329_/Y _3339_/C1 VGND VGND VPWR VPWR _3339_/Y sky130_fd_sc_hd__a211oi_4
XFILLER_100_587 VGND VGND VPWR VPWR sky130_fd_sc_hd__fill_1
XFILLER_39_671 VGND VGND VPWR VPWR sky130_fd_sc_hd__fill_1
XFILLER_46_619 VGND VGND VPWR VPWR sky130_fd_sc_hd__decap_3
XFILLER_65_27 VGND VGND VPWR VPWR sky130_fd_sc_hd__decap_3
XFILLER_100_598 VGND VGND VPWR VPWR sky130_fd_sc_hd__decap_3
XFILLER_39_682 VGND VGND VPWR VPWR sky130_fd_sc_hd__decap_3
XFILLER_73_438 VGND VGND VPWR VPWR sky130_fd_sc_hd__fill_1
XFILLER_73_449 VGND VGND VPWR VPWR sky130_fd_sc_hd__fill_1
XFILLER_85_287 VGND VGND VPWR VPWR sky130_fd_sc_hd__decap_3
XFILLER_85_298 VGND VGND VPWR VPWR sky130_fd_sc_hd__decap_3
X_5009_ _5009_/A _5009_/B VGND VGND VPWR VPWR _5010_/D sky130_fd_sc_hd__nor2_2
XFILLER_26_365 VGND VGND VPWR VPWR sky130_fd_sc_hd__decap_3
XFILLER_38_192 VGND VGND VPWR VPWR sky130_fd_sc_hd__decap_3
XFILLER_54_663 VGND VGND VPWR VPWR sky130_fd_sc_hd__decap_3
XFILLER_26_398 VGND VGND VPWR VPWR sky130_fd_sc_hd__decap_3
XFILLER_53_151 VGND VGND VPWR VPWR sky130_fd_sc_hd__fill_1
XFILLER_41_357 VGND VGND VPWR VPWR sky130_fd_sc_hd__fill_1
XTAP_TAPCELL_ROW_24_544 VGND VPWR sky130_fd_sc_hd__tapvpwrvgnd_1
XFILLER_22_571 VGND VGND VPWR VPWR sky130_fd_sc_hd__decap_3
XFILLER_41_379 VGND VGND VPWR VPWR sky130_fd_sc_hd__decap_3
XTAP_TAPCELL_ROW_52_875 VGND VPWR sky130_fd_sc_hd__tapvpwrvgnd_1
XFILLER_108_610 VGND VGND VPWR VPWR sky130_fd_sc_hd__decap_3
XFILLER_108_643 VGND VGND VPWR VPWR sky130_fd_sc_hd__fill_1
XFILLER_108_654 VGND VGND VPWR VPWR sky130_fd_sc_hd__decap_3
XFILLER_5_225 VGND VGND VPWR VPWR sky130_fd_sc_hd__decap_3
XFILLER_107_164 VGND VGND VPWR VPWR sky130_fd_sc_hd__decap_3
XFILLER_108_687 VGND VGND VPWR VPWR sky130_fd_sc_hd__decap_3
XFILLER_30_63 VGND VGND VPWR VPWR sky130_fd_sc_hd__decap_3
XFILLER_107_186 VGND VGND VPWR VPWR sky130_fd_sc_hd__decap_3
XFILLER_30_85 VGND VGND VPWR VPWR sky130_fd_sc_hd__decap_3
XFILLER_1_475 VGND VGND VPWR VPWR sky130_fd_sc_hd__decap_3
XFILLER_39_50 VGND VGND VPWR VPWR sky130_fd_sc_hd__decap_3
XFILLER_89_582 VGND VGND VPWR VPWR sky130_fd_sc_hd__decap_3
XFILLER_103_381 VGND VGND VPWR VPWR sky130_fd_sc_hd__fill_2
XFILLER_39_94 VGND VGND VPWR VPWR sky130_fd_sc_hd__fill_2
XFILLER_64_438 VGND VGND VPWR VPWR sky130_fd_sc_hd__fill_2
XFILLER_76_298 VGND VGND VPWR VPWR sky130_fd_sc_hd__decap_3
XPHY_EDGE_ROW_101_Right_101 VGND VGND VPWR VPWR sky130_fd_sc_hd__decap_3
XFILLER_17_332 VGND VGND VPWR VPWR sky130_fd_sc_hd__decap_3
XFILLER_45_641 VGND VGND VPWR VPWR sky130_fd_sc_hd__decap_3
XFILLER_91_279 VGND VGND VPWR VPWR sky130_fd_sc_hd__fill_1
XFILLER_45_685 VGND VGND VPWR VPWR sky130_fd_sc_hd__decap_3
XFILLER_60_622 VGND VGND VPWR VPWR sky130_fd_sc_hd__decap_3
XFILLER_72_460 VGND VGND VPWR VPWR sky130_fd_sc_hd__decap_3
XFILLER_32_324 VGND VGND VPWR VPWR sky130_fd_sc_hd__decap_3
XFILLER_60_666 VGND VGND VPWR VPWR sky130_fd_sc_hd__decap_3
XFILLER_20_519 VGND VGND VPWR VPWR sky130_fd_sc_hd__decap_3
XFILLER_13_582 VGND VGND VPWR VPWR sky130_fd_sc_hd__decap_3
XFILLER_40_390 VGND VGND VPWR VPWR sky130_fd_sc_hd__decap_3
XFILLER_71_81 VGND VGND VPWR VPWR sky130_fd_sc_hd__decap_3
XFILLER_9_553 VGND VGND VPWR VPWR sky130_fd_sc_hd__decap_3
XFILLER_9_520 VGND VGND VPWR VPWR sky130_fd_sc_hd__decap_3
XFILLER_9_564 VGND VGND VPWR VPWR sky130_fd_sc_hd__decap_3
XFILLER_9_597 VGND VGND VPWR VPWR sky130_fd_sc_hd__decap_3
XFILLER_58_3 VGND VGND VPWR VPWR sky130_fd_sc_hd__decap_3
X_5360_ _5360_/A0 _4470_/X _7412_/A VGND VGND VPWR VPWR _7151_/D sky130_fd_sc_hd__mux2_2
XFILLER_114_613 VGND VGND VPWR VPWR sky130_fd_sc_hd__decap_3
X_4311_ _4311_/A _4311_/B _4311_/C VGND VGND VPWR VPWR _4311_/X sky130_fd_sc_hd__or3_2
XFILLER_114_657 VGND VGND VPWR VPWR sky130_fd_sc_hd__decap_3
XFILLER_4_291 VGND VGND VPWR VPWR sky130_fd_sc_hd__decap_3
X_7030_ _7351_/CLK _7030_/D _6310_/Y VGND VGND VPWR VPWR _7030_/Q sky130_fd_sc_hd__dfrtp_2
XFILLER_99_379 VGND VGND VPWR VPWR sky130_fd_sc_hd__decap_3
XFILLER_67_232 VGND VGND VPWR VPWR sky130_fd_sc_hd__decap_3
XFILLER_95_541 VGND VGND VPWR VPWR sky130_fd_sc_hd__decap_3
X_4173_ _7072_/Q VGND VGND VPWR VPWR _4173_/Y sky130_fd_sc_hd__inv_2
XFILLER_27_107 VGND VGND VPWR VPWR sky130_fd_sc_hd__decap_3
XFILLER_28_619 VGND VGND VPWR VPWR sky130_fd_sc_hd__decap_3
XFILLER_55_405 VGND VGND VPWR VPWR sky130_fd_sc_hd__decap_3
XFILLER_82_202 VGND VGND VPWR VPWR sky130_fd_sc_hd__decap_3
XFILLER_95_585 VGND VGND VPWR VPWR sky130_fd_sc_hd__decap_3
XFILLER_55_427 VGND VGND VPWR VPWR sky130_fd_sc_hd__decap_3
XFILLER_55_449 VGND VGND VPWR VPWR sky130_fd_sc_hd__decap_3
XFILLER_35_140 VGND VGND VPWR VPWR sky130_fd_sc_hd__decap_3
XFILLER_36_663 VGND VGND VPWR VPWR sky130_fd_sc_hd__decap_3
XFILLER_70_408 VGND VGND VPWR VPWR sky130_fd_sc_hd__decap_3
XFILLER_23_302 VGND VGND VPWR VPWR sky130_fd_sc_hd__decap_3
XFILLER_51_600 VGND VGND VPWR VPWR sky130_fd_sc_hd__decap_3
XFILLER_63_471 VGND VGND VPWR VPWR sky130_fd_sc_hd__decap_3
XFILLER_35_184 VGND VGND VPWR VPWR sky130_fd_sc_hd__decap_3
XFILLER_51_644 VGND VGND VPWR VPWR sky130_fd_sc_hd__decap_3
X_6814_ _6974_/CLK _6814_/D VGND VGND VPWR VPWR _6814_/Q sky130_fd_sc_hd__dfxtp_2
XFILLER_51_688 VGND VGND VPWR VPWR sky130_fd_sc_hd__decap_3
X_6745_ clkload9/A _6745_/D VGND VGND VPWR VPWR _6745_/Q sky130_fd_sc_hd__dfxtp_2
XTAP_TAPCELL_ROW_21_503 VGND VPWR sky130_fd_sc_hd__tapvpwrvgnd_1
XFILLER_109_429 VGND VGND VPWR VPWR sky130_fd_sc_hd__decap_3
X_6676_ _6686_/A VGND VGND VPWR VPWR _6676_/Y sky130_fd_sc_hd__inv_2
X_3888_ _6844_/Q _3888_/A2 _3888_/B1 _6839_/Q VGND VGND VPWR VPWR _3888_/X sky130_fd_sc_hd__a22o_2
XTAP_TAPCELL_ROW_98_1424 VGND VPWR sky130_fd_sc_hd__tapvpwrvgnd_1
XFILLER_105_635 VGND VGND VPWR VPWR sky130_fd_sc_hd__decap_3
XFILLER_2_206 VGND VGND VPWR VPWR sky130_fd_sc_hd__fill_1
X_4509_ hold980/X _3398_/Y _4244_/X VGND VGND VPWR VPWR _7325_/D sky130_fd_sc_hd__a21o_2
XFILLER_105_668 VGND VGND VPWR VPWR sky130_fd_sc_hd__decap_3
XFILLER_105_679 VGND VGND VPWR VPWR sky130_fd_sc_hd__decap_3
XFILLER_2_239 VGND VGND VPWR VPWR sky130_fd_sc_hd__decap_3
X_7228_ _7328_/CLK _7228_/D _6508_/Y VGND VGND VPWR VPWR _7228_/Q sky130_fd_sc_hd__dfrtp_2
XFILLER_116_66 VGND VGND VPWR VPWR sky130_fd_sc_hd__decap_3
XFILLER_116_88 VGND VGND VPWR VPWR sky130_fd_sc_hd__decap_3
XFILLER_58_221 VGND VGND VPWR VPWR sky130_fd_sc_hd__decap_3
XFILLER_76_26 VGND VGND VPWR VPWR sky130_fd_sc_hd__fill_2
XFILLER_86_530 VGND VGND VPWR VPWR sky130_fd_sc_hd__fill_2
X_7159_ _7355_/CLK _7159_/D _6439_/Y VGND VGND VPWR VPWR _7159_/Q sky130_fd_sc_hd__dfrtp_2
XFILLER_100_351 VGND VGND VPWR VPWR sky130_fd_sc_hd__decap_3
XFILLER_18_107 VGND VGND VPWR VPWR sky130_fd_sc_hd__decap_3
XFILLER_46_416 VGND VGND VPWR VPWR sky130_fd_sc_hd__decap_3
XFILLER_86_563 VGND VGND VPWR VPWR sky130_fd_sc_hd__decap_3
XTAP_TAPCELL_ROW_29_603 VGND VPWR sky130_fd_sc_hd__tapvpwrvgnd_1
XTAP_TAPCELL_ROW_57_934 VGND VPWR sky130_fd_sc_hd__tapvpwrvgnd_1
XFILLER_27_641 VGND VGND VPWR VPWR sky130_fd_sc_hd__decap_3
XFILLER_92_14 VGND VGND VPWR VPWR sky130_fd_sc_hd__decap_3
Xclkbuf_leaf_38_clk clkbuf_leaf_1_clk/A VGND VGND VPWR VPWR clkload7/A sky130_fd_sc_hd__clkbuf_16
XTAP_TAPCELL_ROW_1_261 VGND VPWR sky130_fd_sc_hd__tapvpwrvgnd_1
XTAP_TAPCELL_ROW_107_1531 VGND VPWR sky130_fd_sc_hd__tapvpwrvgnd_1
XFILLER_27_685 VGND VGND VPWR VPWR sky130_fd_sc_hd__decap_3
XFILLER_42_622 VGND VGND VPWR VPWR sky130_fd_sc_hd__decap_3
XFILLER_54_460 VGND VGND VPWR VPWR sky130_fd_sc_hd__decap_3
XFILLER_26_195 VGND VGND VPWR VPWR sky130_fd_sc_hd__fill_1
XFILLER_81_290 VGND VGND VPWR VPWR sky130_fd_sc_hd__decap_3
XTAP_TAPCELL_ROW_37_691 VGND VPWR sky130_fd_sc_hd__tapvpwrvgnd_1
XFILLER_14_368 VGND VGND VPWR VPWR sky130_fd_sc_hd__fill_2
XFILLER_14_379 VGND VGND VPWR VPWR sky130_fd_sc_hd__decap_3
XFILLER_41_165 VGND VGND VPWR VPWR sky130_fd_sc_hd__decap_3
XFILLER_42_666 VGND VGND VPWR VPWR sky130_fd_sc_hd__decap_3
XFILLER_10_563 VGND VGND VPWR VPWR sky130_fd_sc_hd__decap_3
XFILLER_6_545 VGND VGND VPWR VPWR sky130_fd_sc_hd__decap_3
XFILLER_108_451 VGND VGND VPWR VPWR sky130_fd_sc_hd__decap_3
XFILLER_6_578 VGND VGND VPWR VPWR sky130_fd_sc_hd__decap_3
XFILLER_108_495 VGND VGND VPWR VPWR sky130_fd_sc_hd__decap_3
XFILLER_6_589 VGND VGND VPWR VPWR sky130_fd_sc_hd__decap_3
XTAP_TAPCELL_ROW_9_361 VGND VPWR sky130_fd_sc_hd__tapvpwrvgnd_1
XTAP_TAPCELL_ROW_71_1107 VGND VPWR sky130_fd_sc_hd__tapvpwrvgnd_1
XPHY_EDGE_ROW_102_Left_219 VGND VGND VPWR VPWR sky130_fd_sc_hd__decap_3
XFILLER_111_638 VGND VGND VPWR VPWR sky130_fd_sc_hd__decap_3
XFILLER_104_690 VGND VGND VPWR VPWR sky130_fd_sc_hd__fill_1
XFILLER_2_12 VGND VGND VPWR VPWR sky130_fd_sc_hd__decap_3
XFILLER_77_552 VGND VGND VPWR VPWR sky130_fd_sc_hd__decap_3
XFILLER_37_449 VGND VGND VPWR VPWR sky130_fd_sc_hd__decap_3
XFILLER_77_585 VGND VGND VPWR VPWR sky130_fd_sc_hd__decap_3
XFILLER_92_533 VGND VGND VPWR VPWR sky130_fd_sc_hd__decap_3
XFILLER_18_663 VGND VGND VPWR VPWR sky130_fd_sc_hd__decap_3
XFILLER_64_268 VGND VGND VPWR VPWR sky130_fd_sc_hd__decap_3
XFILLER_92_566 VGND VGND VPWR VPWR sky130_fd_sc_hd__decap_3
Xclkbuf_leaf_29_clk clkload2/A VGND VGND VPWR VPWR _7322_/CLK sky130_fd_sc_hd__clkbuf_16
XFILLER_33_600 VGND VGND VPWR VPWR sky130_fd_sc_hd__decap_3
XFILLER_33_644 VGND VGND VPWR VPWR sky130_fd_sc_hd__decap_3
XFILLER_45_493 VGND VGND VPWR VPWR sky130_fd_sc_hd__decap_3
XFILLER_60_430 VGND VGND VPWR VPWR sky130_fd_sc_hd__fill_1
X_4860_ _4687_/B _4859_/Y _4983_/A VGND VGND VPWR VPWR _4860_/Y sky130_fd_sc_hd__o21ai_2
XTAP_TAPCELL_ROW_82_1236 VGND VPWR sky130_fd_sc_hd__tapvpwrvgnd_1
XPHY_EDGE_ROW_111_Left_228 VGND VGND VPWR VPWR sky130_fd_sc_hd__decap_3
XFILLER_20_305 VGND VGND VPWR VPWR sky130_fd_sc_hd__decap_3
XFILLER_33_688 VGND VGND VPWR VPWR sky130_fd_sc_hd__decap_3
X_3811_ _3629_/A _3808_/X _3810_/X _3741_/X VGND VGND VPWR VPWR _3811_/X sky130_fd_sc_hd__a22o_2
XFILLER_32_187 VGND VGND VPWR VPWR sky130_fd_sc_hd__fill_2
X_6530_ _6602_/A VGND VGND VPWR VPWR _6530_/Y sky130_fd_sc_hd__inv_2
X_4791_ _4791_/A1 _5664_/A _3697_/Y _4791_/C1 VGND VGND VPWR VPWR _4791_/Y sky130_fd_sc_hd__a211oi_2
XFILLER_13_390 VGND VGND VPWR VPWR sky130_fd_sc_hd__fill_2
X_3742_ _6833_/Q _3890_/B1 _3665_/X _6843_/Q VGND VGND VPWR VPWR _3742_/X sky130_fd_sc_hd__a22o_2
X_6461_ _6620_/A VGND VGND VPWR VPWR _6461_/Y sky130_fd_sc_hd__inv_2
X_3673_ _6856_/Q _6864_/Q _6904_/Q _6912_/Q _3991_/B _3665_/B VGND VGND VPWR VPWR
+ _3673_/X sky130_fd_sc_hd__mux4_2
X_6392_ _6618_/A VGND VGND VPWR VPWR _6392_/Y sky130_fd_sc_hd__inv_2
XFILLER_114_410 VGND VGND VPWR VPWR sky130_fd_sc_hd__decap_3
XFILLER_114_421 VGND VGND VPWR VPWR sky130_fd_sc_hd__decap_3
XFILLER_99_110 VGND VGND VPWR VPWR sky130_fd_sc_hd__fill_2
XFILLER_114_454 VGND VGND VPWR VPWR sky130_fd_sc_hd__decap_3
XTAP_TAPCELL_ROW_93_1365 VGND VPWR sky130_fd_sc_hd__tapvpwrvgnd_1
XFILLER_102_616 VGND VGND VPWR VPWR sky130_fd_sc_hd__decap_3
XFILLER_87_305 VGND VGND VPWR VPWR sky130_fd_sc_hd__decap_3
X_5274_ _5274_/A0 _5079_/X _5286_/S VGND VGND VPWR VPWR _7193_/D sky130_fd_sc_hd__mux2_2
XFILLER_101_137 VGND VGND VPWR VPWR sky130_fd_sc_hd__decap_3
XFILLER_114_498 VGND VGND VPWR VPWR sky130_fd_sc_hd__decap_3
X_7013_ _7392_/CLK _7013_/D _6293_/Y VGND VGND VPWR VPWR _7013_/Q sky130_fd_sc_hd__dfrtp_2
X_4225_ _4371_/A _4371_/B _4224_/C VGND VGND VPWR VPWR _4627_/A sky130_fd_sc_hd__a21oi_2
XFILLER_110_660 VGND VGND VPWR VPWR sky130_fd_sc_hd__decap_3
XFILLER_68_574 VGND VGND VPWR VPWR sky130_fd_sc_hd__decap_3
X_4156_ _4157_/A _4205_/C VGND VGND VPWR VPWR _4158_/A sky130_fd_sc_hd__or2_2
XFILLER_28_438 VGND VGND VPWR VPWR sky130_fd_sc_hd__fill_2
XFILLER_46_29 VGND VGND VPWR VPWR sky130_fd_sc_hd__fill_2
XFILLER_95_393 VGND VGND VPWR VPWR sky130_fd_sc_hd__decap_3
XFILLER_55_235 VGND VGND VPWR VPWR sky130_fd_sc_hd__decap_3
XFILLER_55_246 VGND VGND VPWR VPWR sky130_fd_sc_hd__decap_3
XFILLER_83_544 VGND VGND VPWR VPWR sky130_fd_sc_hd__decap_3
X_4087_ _7078_/Q _4102_/B _4432_/B1 _4086_/X VGND VGND VPWR VPWR _4095_/A sky130_fd_sc_hd__o211ai_2
XTAP_TAPCELL_ROW_54_904 VGND VPWR sky130_fd_sc_hd__tapvpwrvgnd_1
XFILLER_102_35 VGND VGND VPWR VPWR sky130_fd_sc_hd__fill_2
XFILLER_83_588 VGND VGND VPWR VPWR sky130_fd_sc_hd__decap_3
XFILLER_102_79 VGND VGND VPWR VPWR sky130_fd_sc_hd__fill_2
XFILLER_24_622 VGND VGND VPWR VPWR sky130_fd_sc_hd__decap_3
XFILLER_51_430 VGND VGND VPWR VPWR sky130_fd_sc_hd__decap_3
XFILLER_70_238 VGND VGND VPWR VPWR sky130_fd_sc_hd__decap_3
XFILLER_23_165 VGND VGND VPWR VPWR sky130_fd_sc_hd__decap_3
XFILLER_24_666 VGND VGND VPWR VPWR sky130_fd_sc_hd__decap_3
Xplace290 _3913_/B1 VGND VGND VPWR VPWR _3889_/B1 sky130_fd_sc_hd__buf_2
XTAP_TAPCELL_ROW_34_661 VGND VPWR sky130_fd_sc_hd__tapvpwrvgnd_1
X_4989_ _5032_/A _5032_/B VGND VGND VPWR VPWR _4989_/X sky130_fd_sc_hd__or2b_2
XTAP_TAPCELL_ROW_62_992 VGND VPWR sky130_fd_sc_hd__tapvpwrvgnd_1
XTAP_TAPCELL_ROW_102_1472 VGND VPWR sky130_fd_sc_hd__tapvpwrvgnd_1
X_6728_ _6978_/CLK _6728_/D VGND VGND VPWR VPWR _6728_/Q sky130_fd_sc_hd__dfxtp_2
X_6659_ _6662_/A VGND VGND VPWR VPWR _6659_/Y sky130_fd_sc_hd__inv_2
XFILLER_11_65 VGND VGND VPWR VPWR sky130_fd_sc_hd__fill_1
XFILLER_3_526 VGND VGND VPWR VPWR sky130_fd_sc_hd__decap_3
XFILLER_105_432 VGND VGND VPWR VPWR sky130_fd_sc_hd__decap_3
XFILLER_3_559 VGND VGND VPWR VPWR sky130_fd_sc_hd__fill_1
XFILLER_105_465 VGND VGND VPWR VPWR sky130_fd_sc_hd__decap_3
XFILLER_78_327 VGND VGND VPWR VPWR sky130_fd_sc_hd__fill_1
XFILLER_105_498 VGND VGND VPWR VPWR sky130_fd_sc_hd__decap_3
XTAP_TAPCELL_ROW_6_320 VGND VPWR sky130_fd_sc_hd__tapvpwrvgnd_1
XFILLER_93_319 VGND VGND VPWR VPWR sky130_fd_sc_hd__fill_2
XFILLER_101_671 VGND VGND VPWR VPWR sky130_fd_sc_hd__fill_1
XFILLER_101_682 VGND VGND VPWR VPWR sky130_fd_sc_hd__decap_3
XFILLER_19_416 VGND VGND VPWR VPWR sky130_fd_sc_hd__decap_3
XFILLER_46_202 VGND VGND VPWR VPWR sky130_fd_sc_hd__decap_3
XFILLER_59_585 VGND VGND VPWR VPWR sky130_fd_sc_hd__decap_3
XFILLER_74_533 VGND VGND VPWR VPWR sky130_fd_sc_hd__decap_3
XFILLER_100_181 VGND VGND VPWR VPWR sky130_fd_sc_hd__fill_1
XFILLER_19_449 VGND VGND VPWR VPWR sky130_fd_sc_hd__decap_3
XFILLER_46_246 VGND VGND VPWR VPWR sky130_fd_sc_hd__decap_3
XFILLER_74_566 VGND VGND VPWR VPWR sky130_fd_sc_hd__decap_3
XFILLER_15_600 VGND VGND VPWR VPWR sky130_fd_sc_hd__decap_3
XFILLER_15_644 VGND VGND VPWR VPWR sky130_fd_sc_hd__decap_3
XFILLER_42_430 VGND VGND VPWR VPWR sky130_fd_sc_hd__decap_3
XFILLER_15_688 VGND VGND VPWR VPWR sky130_fd_sc_hd__decap_3
XFILLER_42_452 VGND VGND VPWR VPWR sky130_fd_sc_hd__decap_3
XFILLER_14_165 VGND VGND VPWR VPWR sky130_fd_sc_hd__decap_3
XFILLER_14_187 VGND VGND VPWR VPWR sky130_fd_sc_hd__decap_3
XFILLER_30_625 VGND VGND VPWR VPWR sky130_fd_sc_hd__decap_3
XFILLER_30_669 VGND VGND VPWR VPWR sky130_fd_sc_hd__decap_3
XFILLER_52_83 VGND VGND VPWR VPWR sky130_fd_sc_hd__fill_1
XFILLER_10_371 VGND VGND VPWR VPWR sky130_fd_sc_hd__decap_3
XFILLER_10_382 VGND VGND VPWR VPWR sky130_fd_sc_hd__decap_3
XFILLER_6_331 VGND VGND VPWR VPWR sky130_fd_sc_hd__fill_2
XTAP_TAPCELL_ROW_12_399 VGND VPWR sky130_fd_sc_hd__tapvpwrvgnd_1
XFILLER_108_270 VGND VGND VPWR VPWR sky130_fd_sc_hd__decap_3
XFILLER_111_402 VGND VGND VPWR VPWR sky130_fd_sc_hd__decap_3
XFILLER_96_102 VGND VGND VPWR VPWR sky130_fd_sc_hd__decap_3
XFILLER_97_603 VGND VGND VPWR VPWR sky130_fd_sc_hd__decap_3
XFILLER_111_435 VGND VGND VPWR VPWR sky130_fd_sc_hd__decap_3
XFILLER_2_581 VGND VGND VPWR VPWR sky130_fd_sc_hd__decap_3
XFILLER_2_592 VGND VGND VPWR VPWR sky130_fd_sc_hd__decap_3
XFILLER_69_349 VGND VGND VPWR VPWR sky130_fd_sc_hd__decap_3
XFILLER_96_135 VGND VGND VPWR VPWR sky130_fd_sc_hd__fill_2
XFILLER_97_647 VGND VGND VPWR VPWR sky130_fd_sc_hd__decap_3
XFILLER_111_479 VGND VGND VPWR VPWR sky130_fd_sc_hd__decap_3
XFILLER_77_91 VGND VGND VPWR VPWR sky130_fd_sc_hd__decap_3
XFILLER_84_319 VGND VGND VPWR VPWR sky130_fd_sc_hd__fill_1
XFILLER_96_168 VGND VGND VPWR VPWR sky130_fd_sc_hd__decap_3
XFILLER_65_511 VGND VGND VPWR VPWR sky130_fd_sc_hd__decap_3
XFILLER_77_371 VGND VGND VPWR VPWR sky130_fd_sc_hd__decap_3
XFILLER_77_393 VGND VGND VPWR VPWR sky130_fd_sc_hd__decap_3
XFILLER_65_555 VGND VGND VPWR VPWR sky130_fd_sc_hd__decap_3
XFILLER_37_268 VGND VGND VPWR VPWR sky130_fd_sc_hd__decap_3
XFILLER_52_216 VGND VGND VPWR VPWR sky130_fd_sc_hd__decap_3
XFILLER_65_588 VGND VGND VPWR VPWR sky130_fd_sc_hd__decap_3
XFILLER_92_374 VGND VGND VPWR VPWR sky130_fd_sc_hd__decap_3
XFILLER_52_238 VGND VGND VPWR VPWR sky130_fd_sc_hd__decap_3
XFILLER_80_536 VGND VGND VPWR VPWR sky130_fd_sc_hd__decap_3
X_4912_ _4912_/A _4912_/B VGND VGND VPWR VPWR _6997_/D sky130_fd_sc_hd__nor2_2
XFILLER_21_603 VGND VGND VPWR VPWR sky130_fd_sc_hd__decap_3
XFILLER_80_569 VGND VGND VPWR VPWR sky130_fd_sc_hd__decap_3
XFILLER_21_647 VGND VGND VPWR VPWR sky130_fd_sc_hd__decap_3
XFILLER_60_282 VGND VGND VPWR VPWR sky130_fd_sc_hd__decap_3
X_4843_ _4111_/B _4842_/X _4633_/A VGND VGND VPWR VPWR _4843_/Y sky130_fd_sc_hd__a21oi_2
XTAP_TAPCELL_ROW_31_620 VGND VPWR sky130_fd_sc_hd__tapvpwrvgnd_1
XFILLER_20_124 VGND VGND VPWR VPWR sky130_fd_sc_hd__decap_3
XFILLER_20_157 VGND VGND VPWR VPWR sky130_fd_sc_hd__decap_3
X_4774_ _7004_/Q _4801_/A VGND VGND VPWR VPWR _4775_/B sky130_fd_sc_hd__nor2_2
X_6513_ _6614_/A VGND VGND VPWR VPWR _6513_/Y sky130_fd_sc_hd__inv_2
X_3725_ _3735_/A _3741_/B _3733_/C VGND VGND VPWR VPWR _3725_/X sky130_fd_sc_hd__and3_2
Xclkbuf_leaf_9_clk clkbuf_leaf_9_clk/A VGND VGND VPWR VPWR _6965_/CLK sky130_fd_sc_hd__clkbuf_16
X_6444_ _6542_/A VGND VGND VPWR VPWR _6444_/Y sky130_fd_sc_hd__inv_2
X_3656_ _3991_/B _3665_/B VGND VGND VPWR VPWR _5660_/B sky130_fd_sc_hd__nor2_2
X_6375_ _6567_/A VGND VGND VPWR VPWR _6375_/Y sky130_fd_sc_hd__inv_2
X_3587_ _3599_/A _3600_/A VGND VGND VPWR VPWR _4292_/B sky130_fd_sc_hd__or2_4
XFILLER_88_625 VGND VGND VPWR VPWR sky130_fd_sc_hd__decap_3
XFILLER_102_424 VGND VGND VPWR VPWR sky130_fd_sc_hd__decap_3
XFILLER_87_113 VGND VGND VPWR VPWR sky130_fd_sc_hd__decap_3
XFILLER_102_468 VGND VGND VPWR VPWR sky130_fd_sc_hd__decap_3
XFILLER_57_39 VGND VGND VPWR VPWR sky130_fd_sc_hd__decap_3
XFILLER_88_669 VGND VGND VPWR VPWR sky130_fd_sc_hd__decap_3
X_4208_ _4886_/A _4208_/B VGND VGND VPWR VPWR _4903_/A sky130_fd_sc_hd__nor2_2
XFILLER_56_511 VGND VGND VPWR VPWR sky130_fd_sc_hd__fill_2
XFILLER_56_522 VGND VGND VPWR VPWR sky130_fd_sc_hd__fill_1
X_5188_ _5188_/A _5190_/B VGND VGND VPWR VPWR _7234_/D sky130_fd_sc_hd__and2_2
XTAP_TAPCELL_ROW_39_720 VGND VPWR sky130_fd_sc_hd__tapvpwrvgnd_1
XFILLER_113_23 VGND VGND VPWR VPWR sky130_fd_sc_hd__decap_3
XFILLER_28_224 VGND VGND VPWR VPWR sky130_fd_sc_hd__decap_3
XFILLER_56_533 VGND VGND VPWR VPWR sky130_fd_sc_hd__decap_3
X_4139_ _4207_/A _4642_/B VGND VGND VPWR VPWR _4886_/A sky130_fd_sc_hd__nor2_2
XFILLER_113_78 VGND VGND VPWR VPWR sky130_fd_sc_hd__decap_3
XFILLER_16_408 VGND VGND VPWR VPWR sky130_fd_sc_hd__decap_3
XFILLER_28_268 VGND VGND VPWR VPWR sky130_fd_sc_hd__decap_3
XFILLER_43_205 VGND VGND VPWR VPWR sky130_fd_sc_hd__decap_3
XFILLER_71_503 VGND VGND VPWR VPWR sky130_fd_sc_hd__fill_1
XFILLER_73_38 VGND VGND VPWR VPWR sky130_fd_sc_hd__fill_2
XFILLER_83_352 VGND VGND VPWR VPWR sky130_fd_sc_hd__fill_2
XFILLER_71_558 VGND VGND VPWR VPWR sky130_fd_sc_hd__fill_2
XTAP_TAPCELL_ROW_104_1501 VGND VPWR sky130_fd_sc_hd__tapvpwrvgnd_1
XFILLER_24_452 VGND VGND VPWR VPWR sky130_fd_sc_hd__decap_3
XFILLER_11_113 VGND VGND VPWR VPWR sky130_fd_sc_hd__decap_3
XFILLER_12_625 VGND VGND VPWR VPWR sky130_fd_sc_hd__decap_3
XFILLER_51_260 VGND VGND VPWR VPWR sky130_fd_sc_hd__decap_3
XFILLER_11_135 VGND VGND VPWR VPWR sky130_fd_sc_hd__decap_3
XFILLER_12_669 VGND VGND VPWR VPWR sky130_fd_sc_hd__decap_3
XFILLER_8_607 VGND VGND VPWR VPWR sky130_fd_sc_hd__decap_3
XFILLER_3_312 VGND VGND VPWR VPWR sky130_fd_sc_hd__decap_3
XTAP_TAPCELL_ROW_115_1630 VGND VPWR sky130_fd_sc_hd__tapvpwrvgnd_1
XFILLER_79_603 VGND VGND VPWR VPWR sky130_fd_sc_hd__decap_3
XFILLER_105_284 VGND VGND VPWR VPWR sky130_fd_sc_hd__fill_1
XFILLER_78_124 VGND VGND VPWR VPWR sky130_fd_sc_hd__decap_3
XFILLER_79_647 VGND VGND VPWR VPWR sky130_fd_sc_hd__decap_3
XFILLER_78_168 VGND VGND VPWR VPWR sky130_fd_sc_hd__decap_3
XFILLER_94_628 VGND VGND VPWR VPWR sky130_fd_sc_hd__decap_3
XFILLER_47_50 VGND VGND VPWR VPWR sky130_fd_sc_hd__decap_3
XFILLER_59_393 VGND VGND VPWR VPWR sky130_fd_sc_hd__decap_3
XFILLER_74_330 VGND VGND VPWR VPWR sky130_fd_sc_hd__decap_3
XFILLER_86_190 VGND VGND VPWR VPWR sky130_fd_sc_hd__decap_3
XFILLER_47_588 VGND VGND VPWR VPWR sky130_fd_sc_hd__decap_3
XFILLER_62_514 VGND VGND VPWR VPWR sky130_fd_sc_hd__decap_3
XFILLER_34_238 VGND VGND VPWR VPWR sky130_fd_sc_hd__fill_1
XFILLER_62_536 VGND VGND VPWR VPWR sky130_fd_sc_hd__decap_3
XTAP_TAPCELL_ROW_66_1039 VGND VPWR sky130_fd_sc_hd__tapvpwrvgnd_1
XFILLER_15_430 VGND VGND VPWR VPWR sky130_fd_sc_hd__fill_1
XFILLER_27_290 VGND VGND VPWR VPWR sky130_fd_sc_hd__decap_3
XFILLER_62_569 VGND VGND VPWR VPWR sky130_fd_sc_hd__decap_3
XTAP_TAPCELL_ROW_17_458 VGND VPWR sky130_fd_sc_hd__tapvpwrvgnd_1
Xclkbuf_3_4__f_clk clkbuf_0_clk/X VGND VGND VPWR VPWR clkbuf_leaf_9_clk/A sky130_fd_sc_hd__clkbuf_16
XTAP_TAPCELL_ROW_45_789 VGND VPWR sky130_fd_sc_hd__tapvpwrvgnd_1
XFILLER_30_444 VGND VGND VPWR VPWR sky130_fd_sc_hd__fill_2
XFILLER_8_11 VGND VGND VPWR VPWR sky130_fd_sc_hd__fill_1
XFILLER_30_477 VGND VGND VPWR VPWR sky130_fd_sc_hd__decap_3
XFILLER_116_505 VGND VGND VPWR VPWR sky130_fd_sc_hd__decap_3
X_3510_ _3330_/Y _3383_/B _3442_/B _3331_/B VGND VGND VPWR VPWR _3510_/X sky130_fd_sc_hd__a2bb2o_2
XFILLER_116_527 VGND VGND VPWR VPWR sky130_fd_sc_hd__decap_3
XFILLER_7_662 VGND VGND VPWR VPWR sky130_fd_sc_hd__decap_3
XFILLER_7_673 VGND VGND VPWR VPWR sky130_fd_sc_hd__decap_3
Xhold607 _6909_/Q VGND VGND VPWR VPWR _6909_/D sky130_fd_sc_hd__dlygate4sd3_1
Xhold618 _6978_/Q VGND VGND VPWR VPWR _6978_/D sky130_fd_sc_hd__dlygate4sd3_1
Xwire571 _6645_/A VGND VGND VPWR VPWR _6653_/A sky130_fd_sc_hd__buf_2
XFILLER_116_549 VGND VGND VPWR VPWR sky130_fd_sc_hd__decap_3
Xhold629 _6927_/Q VGND VGND VPWR VPWR _6927_/D sky130_fd_sc_hd__dlygate4sd3_1
X_3441_ _7058_/Q _4305_/B _4460_/A _3440_/X VGND VGND VPWR VPWR _3544_/A sky130_fd_sc_hd__o211ai_2
XTAP_TAPCELL_ROW_77_1179 VGND VPWR sky130_fd_sc_hd__tapvpwrvgnd_1
XFILLER_40_3 VGND VGND VPWR VPWR sky130_fd_sc_hd__decap_3
XFILLER_97_411 VGND VGND VPWR VPWR sky130_fd_sc_hd__fill_1
X_5111_ _3610_/A _3603_/Y _4292_/C _3548_/X VGND VGND VPWR VPWR _5111_/X sky130_fd_sc_hd__a31o_2
XTAP_TAPCELL_ROW_90_1335 VGND VPWR sky130_fd_sc_hd__tapvpwrvgnd_1
XFILLER_69_157 VGND VGND VPWR VPWR sky130_fd_sc_hd__decap_3
XFILLER_85_606 VGND VGND VPWR VPWR sky130_fd_sc_hd__decap_3
XFILLER_85_617 VGND VGND VPWR VPWR sky130_fd_sc_hd__decap_3
XFILLER_111_287 VGND VGND VPWR VPWR sky130_fd_sc_hd__decap_3
XFILLER_97_488 VGND VGND VPWR VPWR sky130_fd_sc_hd__decap_3
XFILLER_111_298 VGND VGND VPWR VPWR sky130_fd_sc_hd__fill_2
XFILLER_38_533 VGND VGND VPWR VPWR sky130_fd_sc_hd__fill_1
XFILLER_65_330 VGND VGND VPWR VPWR sky130_fd_sc_hd__decap_3
XFILLER_93_650 VGND VGND VPWR VPWR sky130_fd_sc_hd__decap_3
XFILLER_38_566 VGND VGND VPWR VPWR sky130_fd_sc_hd__decap_3
XFILLER_65_385 VGND VGND VPWR VPWR sky130_fd_sc_hd__decap_3
XFILLER_65_396 VGND VGND VPWR VPWR sky130_fd_sc_hd__decap_3
X_6993_ _7144_/CLK _6993_/D _6273_/Y VGND VGND VPWR VPWR _6993_/Q sky130_fd_sc_hd__dfrtp_2
XFILLER_80_377 VGND VGND VPWR VPWR sky130_fd_sc_hd__decap_3
XFILLER_21_411 VGND VGND VPWR VPWR sky130_fd_sc_hd__fill_2
XFILLER_80_399 VGND VGND VPWR VPWR sky130_fd_sc_hd__decap_3
XFILLER_33_293 VGND VGND VPWR VPWR sky130_fd_sc_hd__decap_3
XFILLER_61_591 VGND VGND VPWR VPWR sky130_fd_sc_hd__decap_3
X_4826_ _4826_/A _4826_/B VGND VGND VPWR VPWR _7001_/D sky130_fd_sc_hd__nor2_2
X_4757_ _4757_/A _4665_/X VGND VGND VPWR VPWR _4759_/A sky130_fd_sc_hd__or2b_2
XFILLER_107_505 VGND VGND VPWR VPWR sky130_fd_sc_hd__decap_3
XFILLER_107_538 VGND VGND VPWR VPWR sky130_fd_sc_hd__decap_3
XFILLER_111_9 VGND VGND VPWR VPWR sky130_fd_sc_hd__decap_3
X_4688_ _7001_/Q _7002_/Q _4687_/B _5622_/B VGND VGND VPWR VPWR _4688_/X sky130_fd_sc_hd__a31o_2
X_3708_ _6801_/Q _3918_/B1 _3917_/A2 _6711_/Q _3707_/X VGND VGND VPWR VPWR _3708_/X
+ sky130_fd_sc_hd__a221o_2
XFILLER_108_12 VGND VGND VPWR VPWR sky130_fd_sc_hd__decap_3
X_6427_ _6617_/A VGND VGND VPWR VPWR _6427_/Y sky130_fd_sc_hd__inv_2
X_3639_ _3636_/Y _3548_/X _3505_/X _5020_/A _3638_/X VGND VGND VPWR VPWR _3639_/X
+ sky130_fd_sc_hd__o221a_2
X_6358_ _6685_/A VGND VGND VPWR VPWR _6358_/Y sky130_fd_sc_hd__inv_2
XFILLER_0_304 VGND VGND VPWR VPWR sky130_fd_sc_hd__decap_3
XFILLER_102_221 VGND VGND VPWR VPWR sky130_fd_sc_hd__decap_3
XFILLER_115_582 VGND VGND VPWR VPWR sky130_fd_sc_hd__decap_3
XFILLER_68_27 VGND VGND VPWR VPWR sky130_fd_sc_hd__fill_1
XFILLER_88_433 VGND VGND VPWR VPWR sky130_fd_sc_hd__fill_2
XFILLER_0_348 VGND VGND VPWR VPWR sky130_fd_sc_hd__decap_3
XFILLER_102_232 VGND VGND VPWR VPWR sky130_fd_sc_hd__decap_3
X_6289_ _6683_/A VGND VGND VPWR VPWR _6289_/Y sky130_fd_sc_hd__inv_2
XFILLER_75_105 VGND VGND VPWR VPWR sky130_fd_sc_hd__decap_3
XFILLER_76_628 VGND VGND VPWR VPWR sky130_fd_sc_hd__decap_3
XFILLER_88_488 VGND VGND VPWR VPWR sky130_fd_sc_hd__fill_1
XTAP_TAPCELL_ROW_110_1571 VGND VPWR sky130_fd_sc_hd__tapvpwrvgnd_1
XFILLER_29_544 VGND VGND VPWR VPWR sky130_fd_sc_hd__decap_3
XFILLER_56_341 VGND VGND VPWR VPWR sky130_fd_sc_hd__decap_3
XFILLER_75_149 VGND VGND VPWR VPWR sky130_fd_sc_hd__decap_3
XFILLER_91_609 VGND VGND VPWR VPWR sky130_fd_sc_hd__decap_3
XFILLER_17_20 VGND VGND VPWR VPWR sky130_fd_sc_hd__decap_3
XFILLER_29_588 VGND VGND VPWR VPWR sky130_fd_sc_hd__decap_3
XFILLER_56_374 VGND VGND VPWR VPWR sky130_fd_sc_hd__decap_3
XFILLER_84_672 VGND VGND VPWR VPWR sky130_fd_sc_hd__decap_3
XFILLER_90_119 VGND VGND VPWR VPWR sky130_fd_sc_hd__decap_3
XFILLER_71_322 VGND VGND VPWR VPWR sky130_fd_sc_hd__decap_3
XFILLER_31_208 VGND VGND VPWR VPWR sky130_fd_sc_hd__decap_3
XFILLER_44_569 VGND VGND VPWR VPWR sky130_fd_sc_hd__decap_3
XFILLER_12_411 VGND VGND VPWR VPWR sky130_fd_sc_hd__decap_3
XFILLER_24_271 VGND VGND VPWR VPWR sky130_fd_sc_hd__decap_3
XFILLER_52_580 VGND VGND VPWR VPWR sky130_fd_sc_hd__decap_3
XTAP_TAPCELL_ROW_14_417 VGND VPWR sky130_fd_sc_hd__tapvpwrvgnd_1
XTAP_TAPCELL_ROW_42_759 VGND VPWR sky130_fd_sc_hd__tapvpwrvgnd_1
XFILLER_12_477 VGND VGND VPWR VPWR sky130_fd_sc_hd__fill_2
XFILLER_4_610 VGND VGND VPWR VPWR sky130_fd_sc_hd__decap_3
XFILLER_4_643 VGND VGND VPWR VPWR sky130_fd_sc_hd__fill_1
XFILLER_106_560 VGND VGND VPWR VPWR sky130_fd_sc_hd__decap_3
XFILLER_113_508 VGND VGND VPWR VPWR sky130_fd_sc_hd__decap_3
XFILLER_4_654 VGND VGND VPWR VPWR sky130_fd_sc_hd__decap_3
XFILLER_98_208 VGND VGND VPWR VPWR sky130_fd_sc_hd__fill_1
XFILLER_4_687 VGND VGND VPWR VPWR sky130_fd_sc_hd__decap_3
XFILLER_67_606 VGND VGND VPWR VPWR sky130_fd_sc_hd__decap_3
XFILLER_67_617 VGND VGND VPWR VPWR sky130_fd_sc_hd__decap_3
XFILLER_79_499 VGND VGND VPWR VPWR sky130_fd_sc_hd__fill_2
XFILLER_66_149 VGND VGND VPWR VPWR sky130_fd_sc_hd__fill_2
XFILLER_94_458 VGND VGND VPWR VPWR sky130_fd_sc_hd__fill_1
XFILLER_35_503 VGND VGND VPWR VPWR sky130_fd_sc_hd__fill_1
XFILLER_35_514 VGND VGND VPWR VPWR sky130_fd_sc_hd__decap_3
XFILLER_75_650 VGND VGND VPWR VPWR sky130_fd_sc_hd__decap_3
XFILLER_47_396 VGND VGND VPWR VPWR sky130_fd_sc_hd__decap_3
XFILLER_74_171 VGND VGND VPWR VPWR sky130_fd_sc_hd__decap_3
XFILLER_90_631 VGND VGND VPWR VPWR sky130_fd_sc_hd__decap_3
XFILLER_90_675 VGND VGND VPWR VPWR sky130_fd_sc_hd__decap_3
XFILLER_15_260 VGND VGND VPWR VPWR sky130_fd_sc_hd__decap_3
XFILLER_15_271 VGND VGND VPWR VPWR sky130_fd_sc_hd__decap_3
XFILLER_22_208 VGND VGND VPWR VPWR sky130_fd_sc_hd__decap_3
XFILLER_15_293 VGND VGND VPWR VPWR sky130_fd_sc_hd__decap_3
XFILLER_43_591 VGND VGND VPWR VPWR sky130_fd_sc_hd__decap_3
X_5660_ _5660_/A _5660_/B _5660_/C _5660_/D VGND VGND VPWR VPWR _5661_/D sky130_fd_sc_hd__and4_2
XFILLER_88_3 VGND VGND VPWR VPWR sky130_fd_sc_hd__decap_3
XFILLER_90_80 VGND VGND VPWR VPWR sky130_fd_sc_hd__decap_3
X_4611_ _4611_/A VGND VGND VPWR VPWR _4611_/Y sky130_fd_sc_hd__inv_2
XFILLER_30_274 VGND VGND VPWR VPWR sky130_fd_sc_hd__decap_3
XFILLER_30_296 VGND VGND VPWR VPWR sky130_fd_sc_hd__decap_3
X_5591_ _5591_/A _5595_/B VGND VGND VPWR VPWR _7032_/D sky130_fd_sc_hd__or2_2
X_7330_ _7332_/CLK _7330_/D _6610_/Y VGND VGND VPWR VPWR _7330_/Q sky130_fd_sc_hd__dfrtp_2
X_4542_ _4542_/A _4563_/B VGND VGND VPWR VPWR _7309_/D sky130_fd_sc_hd__and2_2
X_7261_ _7353_/CLK _7261_/D _6541_/Y VGND VGND VPWR VPWR _7261_/Q sky130_fd_sc_hd__dfrtp_2
XFILLER_104_519 VGND VGND VPWR VPWR sky130_fd_sc_hd__decap_3
XFILLER_116_368 VGND VGND VPWR VPWR sky130_fd_sc_hd__decap_3
X_3424_ _3398_/Y _3419_/Y _3424_/S VGND VGND VPWR VPWR _3590_/C sky130_fd_sc_hd__mux2_4
X_7192_ _7392_/CLK _7192_/D _6472_/Y VGND VGND VPWR VPWR _7192_/Q sky130_fd_sc_hd__dfrtp_2
XPHY_EDGE_ROW_115_Right_115 VGND VGND VPWR VPWR sky130_fd_sc_hd__decap_3
X_3355_ _3371_/A _5668_/A _3519_/B VGND VGND VPWR VPWR _3355_/Y sky130_fd_sc_hd__o21ai_2
XFILLER_112_563 VGND VGND VPWR VPWR sky130_fd_sc_hd__decap_3
XFILLER_58_628 VGND VGND VPWR VPWR sky130_fd_sc_hd__decap_3
XFILLER_85_414 VGND VGND VPWR VPWR sky130_fd_sc_hd__fill_2
Xhold1104 _7331_/Q VGND VGND VPWR VPWR _4497_/A0 sky130_fd_sc_hd__dlygate4sd3_1
Xhold1115 _7180_/Q VGND VGND VPWR VPWR _5300_/A0 sky130_fd_sc_hd__dlygate4sd3_1
XFILLER_73_609 VGND VGND VPWR VPWR sky130_fd_sc_hd__decap_3
Xhold1126 _7170_/Q VGND VGND VPWR VPWR _5321_/A0 sky130_fd_sc_hd__dlygate4sd3_1
Xhold1137 _7133_/Q VGND VGND VPWR VPWR _5400_/A0 sky130_fd_sc_hd__dlygate4sd3_1
Xhold1148 _7134_/Q VGND VGND VPWR VPWR _5398_/A0 sky130_fd_sc_hd__dlygate4sd3_1
X_5025_ _6989_/Q _5044_/A _6990_/Q VGND VGND VPWR VPWR _5026_/B sky130_fd_sc_hd__a21oi_2
XFILLER_38_363 VGND VGND VPWR VPWR sky130_fd_sc_hd__fill_1
XFILLER_66_672 VGND VGND VPWR VPWR sky130_fd_sc_hd__decap_3
Xhold1159 _7330_/Q VGND VGND VPWR VPWR _4499_/A0 sky130_fd_sc_hd__dlygate4sd3_1
XFILLER_53_311 VGND VGND VPWR VPWR sky130_fd_sc_hd__decap_3
XFILLER_81_620 VGND VGND VPWR VPWR sky130_fd_sc_hd__decap_3
XFILLER_80_130 VGND VGND VPWR VPWR sky130_fd_sc_hd__decap_3
XFILLER_80_141 VGND VGND VPWR VPWR sky130_fd_sc_hd__decap_3
XFILLER_81_653 VGND VGND VPWR VPWR sky130_fd_sc_hd__decap_3
X_6976_ clkload6/A _6976_/D VGND VGND VPWR VPWR _6976_/Q sky130_fd_sc_hd__dfxtp_2
XFILLER_110_24 VGND VGND VPWR VPWR sky130_fd_sc_hd__decap_3
XFILLER_110_35 VGND VGND VPWR VPWR sky130_fd_sc_hd__decap_3
XFILLER_13_208 VGND VGND VPWR VPWR sky130_fd_sc_hd__decap_3
XFILLER_34_580 VGND VGND VPWR VPWR sky130_fd_sc_hd__decap_3
XFILLER_80_174 VGND VGND VPWR VPWR sky130_fd_sc_hd__fill_1
XFILLER_110_68 VGND VGND VPWR VPWR sky130_fd_sc_hd__decap_3
XFILLER_21_252 VGND VGND VPWR VPWR sky130_fd_sc_hd__decap_3
X_4809_ _7002_/Q _4826_/A VGND VGND VPWR VPWR _7002_/D sky130_fd_sc_hd__xor2_2
XPHY_EDGE_ROW_17_Right_17 VGND VGND VPWR VPWR sky130_fd_sc_hd__decap_3
XFILLER_107_335 VGND VGND VPWR VPWR sky130_fd_sc_hd__fill_1
XFILLER_107_346 VGND VGND VPWR VPWR sky130_fd_sc_hd__decap_3
XFILLER_79_37 VGND VGND VPWR VPWR sky130_fd_sc_hd__fill_2
XTAP_TAPCELL_ROW_112_1600 VGND VPWR sky130_fd_sc_hd__tapvpwrvgnd_1
XFILLER_1_613 VGND VGND VPWR VPWR sky130_fd_sc_hd__decap_3
XFILLER_1_635 VGND VGND VPWR VPWR sky130_fd_sc_hd__decap_3
Xhold982 _7047_/Q VGND VGND VPWR VPWR hold982/X sky130_fd_sc_hd__dlygate4sd3_1
Xhold971 _7401_/Q VGND VGND VPWR VPWR hold971/X sky130_fd_sc_hd__dlygate4sd3_1
Xhold960 _7013_/Q VGND VGND VPWR VPWR _5630_/A sky130_fd_sc_hd__dlygate4sd3_1
XFILLER_103_541 VGND VGND VPWR VPWR sky130_fd_sc_hd__decap_3
XFILLER_1_668 VGND VGND VPWR VPWR sky130_fd_sc_hd__decap_3
XFILLER_49_606 VGND VGND VPWR VPWR sky130_fd_sc_hd__decap_3
XFILLER_95_14 VGND VGND VPWR VPWR sky130_fd_sc_hd__decap_3
Xhold993 _7199_/Q VGND VGND VPWR VPWR hold993/X sky130_fd_sc_hd__dlygate4sd3_1
XFILLER_103_585 VGND VGND VPWR VPWR sky130_fd_sc_hd__decap_3
XFILLER_1_679 VGND VGND VPWR VPWR sky130_fd_sc_hd__decap_3
XFILLER_49_617 VGND VGND VPWR VPWR sky130_fd_sc_hd__decap_3
XPHY_EDGE_ROW_26_Right_26 VGND VGND VPWR VPWR sky130_fd_sc_hd__decap_3
XFILLER_29_352 VGND VGND VPWR VPWR sky130_fd_sc_hd__decap_3
XFILLER_57_650 VGND VGND VPWR VPWR sky130_fd_sc_hd__decap_3
XTAP_TAPCELL_ROW_47_818 VGND VPWR sky130_fd_sc_hd__tapvpwrvgnd_1
XFILLER_17_547 VGND VGND VPWR VPWR sky130_fd_sc_hd__decap_3
XFILLER_28_85 VGND VGND VPWR VPWR sky130_fd_sc_hd__fill_2
XFILLER_28_96 VGND VGND VPWR VPWR sky130_fd_sc_hd__decap_3
XFILLER_44_322 VGND VGND VPWR VPWR sky130_fd_sc_hd__decap_3
XFILLER_72_631 VGND VGND VPWR VPWR sky130_fd_sc_hd__decap_3
XFILLER_44_355 VGND VGND VPWR VPWR sky130_fd_sc_hd__decap_3
XFILLER_72_675 VGND VGND VPWR VPWR sky130_fd_sc_hd__decap_3
XFILLER_32_517 VGND VGND VPWR VPWR sky130_fd_sc_hd__fill_2
XFILLER_32_528 VGND VGND VPWR VPWR sky130_fd_sc_hd__decap_3
XFILLER_71_163 VGND VGND VPWR VPWR sky130_fd_sc_hd__decap_3
XTAP_TAPCELL_ROW_63_1009 VGND VPWR sky130_fd_sc_hd__tapvpwrvgnd_1
XTAP_TAPCELL_ROW_27_575 VGND VPWR sky130_fd_sc_hd__tapvpwrvgnd_1
XFILLER_25_591 VGND VGND VPWR VPWR sky130_fd_sc_hd__decap_3
XFILLER_40_572 VGND VGND VPWR VPWR sky130_fd_sc_hd__decap_3
XPHY_EDGE_ROW_35_Right_35 VGND VGND VPWR VPWR sky130_fd_sc_hd__decap_3
XFILLER_12_285 VGND VGND VPWR VPWR sky130_fd_sc_hd__decap_3
XFILLER_8_245 VGND VGND VPWR VPWR sky130_fd_sc_hd__decap_3
XFILLER_8_256 VGND VGND VPWR VPWR sky130_fd_sc_hd__fill_2
XFILLER_8_267 VGND VGND VPWR VPWR sky130_fd_sc_hd__fill_2
XFILLER_5_12 VGND VGND VPWR VPWR sky130_fd_sc_hd__decap_3
Xoutput509 _4791_/C1 VGND VGND VPWR VPWR instruction_out[2] sky130_fd_sc_hd__clkdlybuf4s25_1
XFILLER_99_517 VGND VGND VPWR VPWR sky130_fd_sc_hd__decap_3
XFILLER_113_327 VGND VGND VPWR VPWR sky130_fd_sc_hd__decap_3
XFILLER_4_495 VGND VGND VPWR VPWR sky130_fd_sc_hd__decap_3
XFILLER_5_89 VGND VGND VPWR VPWR sky130_fd_sc_hd__fill_1
XTAP_TAPCELL_ROW_74_1138 VGND VPWR sky130_fd_sc_hd__tapvpwrvgnd_1
XPHY_EDGE_ROW_44_Right_44 VGND VGND VPWR VPWR sky130_fd_sc_hd__decap_3
XFILLER_67_425 VGND VGND VPWR VPWR sky130_fd_sc_hd__decap_3
XFILLER_67_458 VGND VGND VPWR VPWR sky130_fd_sc_hd__decap_3
XFILLER_79_296 VGND VGND VPWR VPWR sky130_fd_sc_hd__decap_3
XFILLER_48_672 VGND VGND VPWR VPWR sky130_fd_sc_hd__decap_3
XFILLER_55_609 VGND VGND VPWR VPWR sky130_fd_sc_hd__decap_3
XFILLER_63_620 VGND VGND VPWR VPWR sky130_fd_sc_hd__decap_3
XFILLER_75_480 VGND VGND VPWR VPWR sky130_fd_sc_hd__fill_1
XFILLER_82_439 VGND VGND VPWR VPWR sky130_fd_sc_hd__decap_3
XFILLER_35_333 VGND VGND VPWR VPWR sky130_fd_sc_hd__decap_3
XFILLER_35_355 VGND VGND VPWR VPWR sky130_fd_sc_hd__decap_3
XFILLER_62_141 VGND VGND VPWR VPWR sky130_fd_sc_hd__fill_2
XFILLER_63_653 VGND VGND VPWR VPWR sky130_fd_sc_hd__decap_3
X_6830_ clkload7/A _6830_/D VGND VGND VPWR VPWR _6830_/Q sky130_fd_sc_hd__dfxtp_2
XFILLER_50_303 VGND VGND VPWR VPWR sky130_fd_sc_hd__decap_3
X_6761_ clkload7/A _6761_/D VGND VGND VPWR VPWR _6761_/Q sky130_fd_sc_hd__dfxtp_2
XTAP_TAPCELL_ROW_85_1267 VGND VPWR sky130_fd_sc_hd__tapvpwrvgnd_1
XFILLER_50_347 VGND VGND VPWR VPWR sky130_fd_sc_hd__decap_3
X_5712_ _7362_/Q hold908/X _5737_/S VGND VGND VPWR VPWR _6706_/D sky130_fd_sc_hd__mux2_2
X_3973_ _7354_/Q _4515_/A0 _3975_/S VGND VGND VPWR VPWR _7354_/D sky130_fd_sc_hd__mux2_2
XPHY_EDGE_ROW_53_Right_53 VGND VGND VPWR VPWR sky130_fd_sc_hd__decap_3
XFILLER_31_561 VGND VGND VPWR VPWR sky130_fd_sc_hd__decap_3
X_6692_ _6966_/CLK _6692_/D VGND VGND VPWR VPWR _6692_/Q sky130_fd_sc_hd__dfxtp_2
XFILLER_31_594 VGND VGND VPWR VPWR sky130_fd_sc_hd__decap_3
X_5643_ _5643_/A VGND VGND VPWR VPWR _5643_/X sky130_fd_sc_hd__buf_1
X_5574_ hold947/X _5587_/B _4983_/X VGND VGND VPWR VPWR _7043_/D sky130_fd_sc_hd__a21o_2
X_7313_ _7351_/CLK _7313_/D _6593_/Y VGND VGND VPWR VPWR _7313_/Q sky130_fd_sc_hd__dfrtp_2
XFILLER_104_327 VGND VGND VPWR VPWR sky130_fd_sc_hd__decap_3
X_7244_ _7372_/CLK _7244_/D _6524_/Y VGND VGND VPWR VPWR _7244_/Q sky130_fd_sc_hd__dfrtp_2
X_4456_ _4456_/A _4054_/A VGND VGND VPWR VPWR _4456_/X sky130_fd_sc_hd__or2b_2
XPHY_EDGE_ROW_62_Right_62 VGND VGND VPWR VPWR sky130_fd_sc_hd__decap_3
X_7175_ _7307_/CLK _7175_/D _6455_/Y VGND VGND VPWR VPWR _7175_/Q sky130_fd_sc_hd__dfrtp_2
X_4387_ _7241_/Q _4430_/A2 _4459_/C1 _7177_/Q _4386_/X VGND VGND VPWR VPWR _4387_/X
+ sky130_fd_sc_hd__a221o_2
X_3407_ _3421_/B _3421_/C _3417_/C VGND VGND VPWR VPWR _3407_/X sky130_fd_sc_hd__and3_2
XFILLER_105_24 VGND VGND VPWR VPWR sky130_fd_sc_hd__decap_3
XFILLER_112_371 VGND VGND VPWR VPWR sky130_fd_sc_hd__fill_2
XFILLER_58_414 VGND VGND VPWR VPWR sky130_fd_sc_hd__decap_3
XFILLER_85_200 VGND VGND VPWR VPWR sky130_fd_sc_hd__decap_3
XFILLER_98_572 VGND VGND VPWR VPWR sky130_fd_sc_hd__decap_3
XFILLER_100_522 VGND VGND VPWR VPWR sky130_fd_sc_hd__decap_3
XFILLER_100_533 VGND VGND VPWR VPWR sky130_fd_sc_hd__decap_3
XFILLER_105_57 VGND VGND VPWR VPWR sky130_fd_sc_hd__decap_3
XFILLER_112_382 VGND VGND VPWR VPWR sky130_fd_sc_hd__decap_3
XFILLER_58_447 VGND VGND VPWR VPWR sky130_fd_sc_hd__decap_3
XFILLER_100_566 VGND VGND VPWR VPWR sky130_fd_sc_hd__decap_3
XFILLER_39_650 VGND VGND VPWR VPWR sky130_fd_sc_hd__decap_3
XFILLER_85_255 VGND VGND VPWR VPWR sky130_fd_sc_hd__decap_3
XFILLER_85_277 VGND VGND VPWR VPWR sky130_fd_sc_hd__decap_3
XFILLER_54_631 VGND VGND VPWR VPWR sky130_fd_sc_hd__decap_3
XFILLER_66_480 VGND VGND VPWR VPWR sky130_fd_sc_hd__fill_2
X_5008_ _4680_/A _5015_/B _5647_/A VGND VGND VPWR VPWR _5009_/B sky130_fd_sc_hd__a21o_2
XFILLER_26_344 VGND VGND VPWR VPWR sky130_fd_sc_hd__decap_3
XFILLER_14_539 VGND VGND VPWR VPWR sky130_fd_sc_hd__decap_3
XFILLER_53_163 VGND VGND VPWR VPWR sky130_fd_sc_hd__decap_3
XFILLER_54_675 VGND VGND VPWR VPWR sky130_fd_sc_hd__decap_3
XPHY_EDGE_ROW_71_Right_71 VGND VGND VPWR VPWR sky130_fd_sc_hd__decap_3
XFILLER_53_196 VGND VGND VPWR VPWR sky130_fd_sc_hd__decap_3
X_6959_ _6959_/CLK _6959_/D VGND VGND VPWR VPWR _6959_/Q sky130_fd_sc_hd__dfxtp_2
XTAP_TAPCELL_ROW_24_545 VGND VPWR sky130_fd_sc_hd__tapvpwrvgnd_1
XTAP_TAPCELL_ROW_24_534 VGND VPWR sky130_fd_sc_hd__tapvpwrvgnd_1
XFILLER_22_550 VGND VGND VPWR VPWR sky130_fd_sc_hd__decap_3
XTAP_TAPCELL_ROW_52_876 VGND VPWR sky130_fd_sc_hd__tapvpwrvgnd_1
XFILLER_22_583 VGND VGND VPWR VPWR sky130_fd_sc_hd__decap_3
XFILLER_108_622 VGND VGND VPWR VPWR sky130_fd_sc_hd__decap_3
XPHY_EDGE_ROW_15_Left_132 VGND VGND VPWR VPWR sky130_fd_sc_hd__decap_3
XFILLER_107_143 VGND VGND VPWR VPWR sky130_fd_sc_hd__decap_3
XFILLER_108_666 VGND VGND VPWR VPWR sky130_fd_sc_hd__decap_3
XFILLER_30_42 VGND VGND VPWR VPWR sky130_fd_sc_hd__fill_1
XFILLER_5_248 VGND VGND VPWR VPWR sky130_fd_sc_hd__decap_3
XPHY_EDGE_ROW_80_Right_80 VGND VGND VPWR VPWR sky130_fd_sc_hd__decap_3
XFILLER_107_198 VGND VGND VPWR VPWR sky130_fd_sc_hd__decap_3
XFILLER_89_550 VGND VGND VPWR VPWR sky130_fd_sc_hd__decap_3
XFILLER_96_509 VGND VGND VPWR VPWR sky130_fd_sc_hd__decap_3
Xhold790 _6952_/Q VGND VGND VPWR VPWR _6952_/D sky130_fd_sc_hd__dlygate4sd3_1
XFILLER_103_360 VGND VGND VPWR VPWR sky130_fd_sc_hd__decap_3
XFILLER_76_200 VGND VGND VPWR VPWR sky130_fd_sc_hd__decap_3
XFILLER_89_561 VGND VGND VPWR VPWR sky130_fd_sc_hd__decap_3
XFILLER_103_393 VGND VGND VPWR VPWR sky130_fd_sc_hd__decap_3
XFILLER_1_487 VGND VGND VPWR VPWR sky130_fd_sc_hd__decap_3
XFILLER_49_458 VGND VGND VPWR VPWR sky130_fd_sc_hd__decap_3
XFILLER_76_222 VGND VGND VPWR VPWR sky130_fd_sc_hd__fill_1
XFILLER_76_233 VGND VGND VPWR VPWR sky130_fd_sc_hd__decap_3
XFILLER_89_594 VGND VGND VPWR VPWR sky130_fd_sc_hd__decap_3
XFILLER_37_609 VGND VGND VPWR VPWR sky130_fd_sc_hd__decap_3
XFILLER_64_406 VGND VGND VPWR VPWR sky130_fd_sc_hd__decap_3
XFILLER_76_266 VGND VGND VPWR VPWR sky130_fd_sc_hd__decap_3
XFILLER_45_620 VGND VGND VPWR VPWR sky130_fd_sc_hd__decap_3
XFILLER_91_203 VGND VGND VPWR VPWR sky130_fd_sc_hd__decap_3
XFILLER_91_225 VGND VGND VPWR VPWR sky130_fd_sc_hd__fill_1
XPHY_EDGE_ROW_24_Left_141 VGND VGND VPWR VPWR sky130_fd_sc_hd__decap_3
XFILLER_17_355 VGND VGND VPWR VPWR sky130_fd_sc_hd__fill_1
XFILLER_44_141 VGND VGND VPWR VPWR sky130_fd_sc_hd__fill_1
XFILLER_45_653 VGND VGND VPWR VPWR sky130_fd_sc_hd__decap_3
XFILLER_72_450 VGND VGND VPWR VPWR sky130_fd_sc_hd__fill_1
XFILLER_91_258 VGND VGND VPWR VPWR sky130_fd_sc_hd__decap_3
XFILLER_44_174 VGND VGND VPWR VPWR sky130_fd_sc_hd__fill_2
XFILLER_60_601 VGND VGND VPWR VPWR sky130_fd_sc_hd__decap_3
XFILLER_72_483 VGND VGND VPWR VPWR sky130_fd_sc_hd__fill_1
XFILLER_17_399 VGND VGND VPWR VPWR sky130_fd_sc_hd__decap_3
XFILLER_32_336 VGND VGND VPWR VPWR sky130_fd_sc_hd__decap_3
XFILLER_60_634 VGND VGND VPWR VPWR sky130_fd_sc_hd__decap_3
XFILLER_60_645 VGND VGND VPWR VPWR sky130_fd_sc_hd__decap_3
XFILLER_13_561 VGND VGND VPWR VPWR sky130_fd_sc_hd__decap_3
XFILLER_32_358 VGND VGND VPWR VPWR sky130_fd_sc_hd__decap_3
XFILLER_60_678 VGND VGND VPWR VPWR sky130_fd_sc_hd__decap_3
XFILLER_13_594 VGND VGND VPWR VPWR sky130_fd_sc_hd__decap_3
XFILLER_9_532 VGND VGND VPWR VPWR sky130_fd_sc_hd__decap_3
XFILLER_72_6 VGND VGND VPWR VPWR sky130_fd_sc_hd__decap_3
XPHY_EDGE_ROW_33_Left_150 VGND VGND VPWR VPWR sky130_fd_sc_hd__decap_3
XFILLER_9_576 VGND VGND VPWR VPWR sky130_fd_sc_hd__decap_3
XFILLER_113_102 VGND VGND VPWR VPWR sky130_fd_sc_hd__fill_1
XFILLER_114_625 VGND VGND VPWR VPWR sky130_fd_sc_hd__decap_3
X_5290_ _5290_/A0 _5156_/X _5292_/S VGND VGND VPWR VPWR _7184_/D sky130_fd_sc_hd__mux2_2
X_4310_ _7352_/Q _4337_/B _4352_/B1 _7160_/Q VGND VGND VPWR VPWR _4311_/C sky130_fd_sc_hd__a22o_2
XFILLER_99_314 VGND VGND VPWR VPWR sky130_fd_sc_hd__decap_3
XFILLER_114_669 VGND VGND VPWR VPWR sky130_fd_sc_hd__decap_3
XFILLER_4_270 VGND VGND VPWR VPWR sky130_fd_sc_hd__decap_3
X_4241_ _5018_/B _4241_/B VGND VGND VPWR VPWR _5032_/A sky130_fd_sc_hd__or2_2
XFILLER_101_319 VGND VGND VPWR VPWR sky130_fd_sc_hd__decap_3
XFILLER_67_211 VGND VGND VPWR VPWR sky130_fd_sc_hd__decap_3
XFILLER_95_520 VGND VGND VPWR VPWR sky130_fd_sc_hd__decap_3
X_4172_ _4938_/B _4379_/B VGND VGND VPWR VPWR _4936_/A sky130_fd_sc_hd__nor2_2
XFILLER_95_553 VGND VGND VPWR VPWR sky130_fd_sc_hd__decap_3
XFILLER_95_564 VGND VGND VPWR VPWR sky130_fd_sc_hd__decap_3
XFILLER_48_480 VGND VGND VPWR VPWR sky130_fd_sc_hd__decap_3
XFILLER_67_299 VGND VGND VPWR VPWR sky130_fd_sc_hd__decap_3
XFILLER_82_214 VGND VGND VPWR VPWR sky130_fd_sc_hd__decap_3
XFILLER_82_225 VGND VGND VPWR VPWR sky130_fd_sc_hd__fill_1
XFILLER_95_597 VGND VGND VPWR VPWR sky130_fd_sc_hd__decap_3
XFILLER_36_631 VGND VGND VPWR VPWR sky130_fd_sc_hd__decap_3
XFILLER_82_236 VGND VGND VPWR VPWR sky130_fd_sc_hd__decap_3
XFILLER_23_314 VGND VGND VPWR VPWR sky130_fd_sc_hd__decap_3
XFILLER_36_675 VGND VGND VPWR VPWR sky130_fd_sc_hd__decap_3
XFILLER_51_612 VGND VGND VPWR VPWR sky130_fd_sc_hd__decap_3
XFILLER_51_623 VGND VGND VPWR VPWR sky130_fd_sc_hd__decap_3
XFILLER_23_325 VGND VGND VPWR VPWR sky130_fd_sc_hd__decap_3
XFILLER_35_196 VGND VGND VPWR VPWR sky130_fd_sc_hd__decap_3
XFILLER_51_656 VGND VGND VPWR VPWR sky130_fd_sc_hd__decap_3
XFILLER_90_280 VGND VGND VPWR VPWR sky130_fd_sc_hd__decap_3
Xplace450 _5129_/A VGND VGND VPWR VPWR _3561_/A sky130_fd_sc_hd__buf_2
X_6813_ _6974_/CLK _6813_/D VGND VGND VPWR VPWR _6813_/Q sky130_fd_sc_hd__dfxtp_2
X_6744_ _6978_/CLK _6744_/D VGND VGND VPWR VPWR _6744_/Q sky130_fd_sc_hd__dfxtp_2
X_3956_ _7362_/Q _4499_/A0 _3958_/S VGND VGND VPWR VPWR _7362_/D sky130_fd_sc_hd__mux2_2
X_6675_ _6685_/A VGND VGND VPWR VPWR _6675_/Y sky130_fd_sc_hd__inv_2
XTAP_TAPCELL_ROW_21_504 VGND VPWR sky130_fd_sc_hd__tapvpwrvgnd_1
XFILLER_109_408 VGND VGND VPWR VPWR sky130_fd_sc_hd__fill_1
X_5626_ _5626_/A _5634_/B VGND VGND VPWR VPWR _7015_/D sky130_fd_sc_hd__and2_2
X_3887_ _6694_/Q _3893_/B1 _3887_/B1 _6872_/Q _3886_/X VGND VGND VPWR VPWR _3887_/X
+ sky130_fd_sc_hd__a221o_2
XTAP_TAPCELL_ROW_98_1425 VGND VPWR sky130_fd_sc_hd__tapvpwrvgnd_1
XFILLER_105_603 VGND VGND VPWR VPWR sky130_fd_sc_hd__decap_3
XFILLER_105_647 VGND VGND VPWR VPWR sky130_fd_sc_hd__decap_3
X_7227_ _7355_/CLK _7227_/D _6507_/Y VGND VGND VPWR VPWR _7227_/Q sky130_fd_sc_hd__dfrtp_2
X_4439_ _4440_/A _4650_/B VGND VGND VPWR VPWR _4813_/B sky130_fd_sc_hd__or2_2
XFILLER_86_542 VGND VGND VPWR VPWR sky130_fd_sc_hd__decap_3
X_7158_ _7351_/CLK _7158_/D _6438_/Y VGND VGND VPWR VPWR _7158_/Q sky130_fd_sc_hd__dfrtp_2
XFILLER_100_330 VGND VGND VPWR VPWR sky130_fd_sc_hd__decap_3
XFILLER_19_609 VGND VGND VPWR VPWR sky130_fd_sc_hd__decap_3
XFILLER_46_406 VGND VGND VPWR VPWR sky130_fd_sc_hd__fill_2
XFILLER_86_575 VGND VGND VPWR VPWR sky130_fd_sc_hd__decap_3
X_7089_ _7317_/CLK _7089_/D _6369_/Y VGND VGND VPWR VPWR _7089_/Q sky130_fd_sc_hd__dfstp_2
XFILLER_27_620 VGND VGND VPWR VPWR sky130_fd_sc_hd__decap_3
XFILLER_39_480 VGND VGND VPWR VPWR sky130_fd_sc_hd__decap_3
XFILLER_46_428 VGND VGND VPWR VPWR sky130_fd_sc_hd__decap_3
XFILLER_73_203 VGND VGND VPWR VPWR sky130_fd_sc_hd__decap_3
XFILLER_73_225 VGND VGND VPWR VPWR sky130_fd_sc_hd__fill_2
XTAP_TAPCELL_ROW_57_935 VGND VPWR sky130_fd_sc_hd__tapvpwrvgnd_1
XTAP_TAPCELL_ROW_29_604 VGND VPWR sky130_fd_sc_hd__tapvpwrvgnd_1
XFILLER_27_653 VGND VGND VPWR VPWR sky130_fd_sc_hd__decap_3
XFILLER_73_236 VGND VGND VPWR VPWR sky130_fd_sc_hd__decap_3
XFILLER_73_258 VGND VGND VPWR VPWR sky130_fd_sc_hd__decap_3
XFILLER_92_26 VGND VGND VPWR VPWR sky130_fd_sc_hd__fill_2
XTAP_TAPCELL_ROW_107_1532 VGND VPWR sky130_fd_sc_hd__tapvpwrvgnd_1
XFILLER_26_141 VGND VGND VPWR VPWR sky130_fd_sc_hd__decap_3
XFILLER_42_601 VGND VGND VPWR VPWR sky130_fd_sc_hd__decap_3
XTAP_TAPCELL_ROW_1_262 VGND VPWR sky130_fd_sc_hd__tapvpwrvgnd_1
XFILLER_42_634 VGND VGND VPWR VPWR sky130_fd_sc_hd__decap_3
XFILLER_42_645 VGND VGND VPWR VPWR sky130_fd_sc_hd__decap_3
XTAP_TAPCELL_ROW_37_692 VGND VPWR sky130_fd_sc_hd__tapvpwrvgnd_1
XFILLER_25_97 VGND VGND VPWR VPWR sky130_fd_sc_hd__decap_3
XFILLER_42_678 VGND VGND VPWR VPWR sky130_fd_sc_hd__decap_3
XFILLER_10_520 VGND VGND VPWR VPWR sky130_fd_sc_hd__decap_3
XFILLER_10_542 VGND VGND VPWR VPWR sky130_fd_sc_hd__decap_3
XFILLER_10_575 VGND VGND VPWR VPWR sky130_fd_sc_hd__decap_3
XFILLER_6_513 VGND VGND VPWR VPWR sky130_fd_sc_hd__decap_3
XFILLER_108_430 VGND VGND VPWR VPWR sky130_fd_sc_hd__decap_3
XFILLER_6_557 VGND VGND VPWR VPWR sky130_fd_sc_hd__decap_3
XFILLER_108_463 VGND VGND VPWR VPWR sky130_fd_sc_hd__decap_3
XTAP_TAPCELL_ROW_71_1108 VGND VPWR sky130_fd_sc_hd__tapvpwrvgnd_1
XFILLER_111_606 VGND VGND VPWR VPWR sky130_fd_sc_hd__decap_3
XFILLER_111_617 VGND VGND VPWR VPWR sky130_fd_sc_hd__decap_3
XFILLER_96_328 VGND VGND VPWR VPWR sky130_fd_sc_hd__decap_3
XTAP_TAPCELL_ROW_9_362 VGND VPWR sky130_fd_sc_hd__tapvpwrvgnd_1
XFILLER_49_222 VGND VGND VPWR VPWR sky130_fd_sc_hd__fill_2
XFILLER_89_380 VGND VGND VPWR VPWR sky130_fd_sc_hd__decap_3
XFILLER_77_564 VGND VGND VPWR VPWR sky130_fd_sc_hd__decap_3
XFILLER_77_597 VGND VGND VPWR VPWR sky130_fd_sc_hd__decap_3
XFILLER_92_523 VGND VGND VPWR VPWR sky130_fd_sc_hd__decap_3
XFILLER_18_631 VGND VGND VPWR VPWR sky130_fd_sc_hd__decap_3
XFILLER_66_82 VGND VGND VPWR VPWR sky130_fd_sc_hd__fill_2
XFILLER_92_545 VGND VGND VPWR VPWR sky130_fd_sc_hd__decap_3
XFILLER_18_675 VGND VGND VPWR VPWR sky130_fd_sc_hd__decap_3
XFILLER_33_612 VGND VGND VPWR VPWR sky130_fd_sc_hd__decap_3
XFILLER_45_472 VGND VGND VPWR VPWR sky130_fd_sc_hd__decap_3
XFILLER_92_578 VGND VGND VPWR VPWR sky130_fd_sc_hd__decap_3
XFILLER_92_589 VGND VGND VPWR VPWR sky130_fd_sc_hd__decap_3
XFILLER_33_623 VGND VGND VPWR VPWR sky130_fd_sc_hd__decap_3
XFILLER_33_656 VGND VGND VPWR VPWR sky130_fd_sc_hd__decap_3
XTAP_TAPCELL_ROW_82_1237 VGND VPWR sky130_fd_sc_hd__tapvpwrvgnd_1
XFILLER_60_453 VGND VGND VPWR VPWR sky130_fd_sc_hd__decap_3
X_4790_ _4781_/X _4782_/Y _4787_/Y _4948_/A _4789_/X VGND VGND VPWR VPWR _5664_/A
+ sky130_fd_sc_hd__o221a_2
X_3810_ _6846_/Q _3879_/A2 _3893_/B1 _6831_/Q _3809_/X VGND VGND VPWR VPWR _3810_/X
+ sky130_fd_sc_hd__a221o_2
XFILLER_20_328 VGND VGND VPWR VPWR sky130_fd_sc_hd__decap_3
X_3741_ _3746_/A _3741_/B _3746_/C VGND VGND VPWR VPWR _3741_/X sky130_fd_sc_hd__and3_4
XFILLER_70_3 VGND VGND VPWR VPWR sky130_fd_sc_hd__decap_3
X_6460_ _6620_/A VGND VGND VPWR VPWR _6460_/Y sky130_fd_sc_hd__inv_2
X_3672_ _3746_/A _3746_/B _3733_/C VGND VGND VPWR VPWR _3672_/X sky130_fd_sc_hd__or3_2
X_6391_ _6617_/A VGND VGND VPWR VPWR _6391_/Y sky130_fd_sc_hd__inv_2
X_5411_ _5411_/A0 _5094_/X _5429_/S VGND VGND VPWR VPWR _7128_/D sky130_fd_sc_hd__mux2_2
X_5342_ _5342_/A0 _5094_/X _5354_/S VGND VGND VPWR VPWR _7160_/D sky130_fd_sc_hd__mux2_2
XFILLER_114_433 VGND VGND VPWR VPWR sky130_fd_sc_hd__decap_3
XTAP_TAPCELL_ROW_93_1366 VGND VPWR sky130_fd_sc_hd__tapvpwrvgnd_1
XFILLER_101_105 VGND VGND VPWR VPWR sky130_fd_sc_hd__decap_3
XFILLER_102_628 VGND VGND VPWR VPWR sky130_fd_sc_hd__decap_3
XFILLER_114_466 VGND VGND VPWR VPWR sky130_fd_sc_hd__decap_3
XFILLER_114_477 VGND VGND VPWR VPWR sky130_fd_sc_hd__decap_3
X_7012_ _7322_/CLK _7012_/D _6292_/Y VGND VGND VPWR VPWR _7012_/Q sky130_fd_sc_hd__dfrtp_2
X_4224_ _4371_/A _4371_/B _4224_/C VGND VGND VPWR VPWR _4372_/A sky130_fd_sc_hd__and3_2
XFILLER_99_188 VGND VGND VPWR VPWR sky130_fd_sc_hd__fill_1
XFILLER_101_149 VGND VGND VPWR VPWR sky130_fd_sc_hd__decap_3
X_4155_ _4151_/X _4154_/X _4327_/A VGND VGND VPWR VPWR _4205_/C sky130_fd_sc_hd__o21ai_2
XFILLER_110_672 VGND VGND VPWR VPWR sky130_fd_sc_hd__decap_3
XFILLER_55_214 VGND VGND VPWR VPWR sky130_fd_sc_hd__decap_3
XFILLER_55_225 VGND VGND VPWR VPWR sky130_fd_sc_hd__decap_3
XFILLER_68_586 VGND VGND VPWR VPWR sky130_fd_sc_hd__fill_2
XFILLER_83_523 VGND VGND VPWR VPWR sky130_fd_sc_hd__decap_3
XFILLER_55_258 VGND VGND VPWR VPWR sky130_fd_sc_hd__decap_3
XFILLER_83_556 VGND VGND VPWR VPWR sky130_fd_sc_hd__decap_3
XFILLER_83_567 VGND VGND VPWR VPWR sky130_fd_sc_hd__decap_3
X_4086_ _7270_/Q _4401_/A2 _4390_/B1 _7334_/Q _4085_/X VGND VGND VPWR VPWR _4086_/X
+ sky130_fd_sc_hd__a221o_2
XFILLER_102_14 VGND VGND VPWR VPWR sky130_fd_sc_hd__decap_3
XFILLER_24_601 VGND VGND VPWR VPWR sky130_fd_sc_hd__decap_3
XFILLER_36_450 VGND VGND VPWR VPWR sky130_fd_sc_hd__decap_3
XFILLER_70_217 VGND VGND VPWR VPWR sky130_fd_sc_hd__decap_3
XTAP_TAPCELL_ROW_54_905 VGND VPWR sky130_fd_sc_hd__tapvpwrvgnd_1
XFILLER_24_634 VGND VGND VPWR VPWR sky130_fd_sc_hd__decap_3
XFILLER_24_645 VGND VGND VPWR VPWR sky130_fd_sc_hd__decap_3
XFILLER_62_18 VGND VGND VPWR VPWR sky130_fd_sc_hd__decap_3
XFILLER_24_678 VGND VGND VPWR VPWR sky130_fd_sc_hd__decap_3
XFILLER_62_29 VGND VGND VPWR VPWR sky130_fd_sc_hd__decap_3
Xplace291 _3925_/A2 VGND VGND VPWR VPWR _3917_/A2 sky130_fd_sc_hd__buf_2
Xplace280 _3926_/A2 VGND VGND VPWR VPWR _3768_/A2 sky130_fd_sc_hd__buf_2
XFILLER_11_328 VGND VGND VPWR VPWR sky130_fd_sc_hd__decap_3
XFILLER_23_177 VGND VGND VPWR VPWR sky130_fd_sc_hd__fill_1
XFILLER_51_475 VGND VGND VPWR VPWR sky130_fd_sc_hd__decap_3
X_4988_ _4988_/A _4988_/B VGND VGND VPWR VPWR _5004_/A sky130_fd_sc_hd__nor2_2
XTAP_TAPCELL_ROW_62_993 VGND VPWR sky130_fd_sc_hd__tapvpwrvgnd_1
XTAP_TAPCELL_ROW_34_662 VGND VPWR sky130_fd_sc_hd__tapvpwrvgnd_1
XTAP_TAPCELL_ROW_102_1473 VGND VPWR sky130_fd_sc_hd__tapvpwrvgnd_1
X_6727_ clkload8/A _6727_/D VGND VGND VPWR VPWR _6727_/Q sky130_fd_sc_hd__dfxtp_2
X_3939_ _7370_/Q _7338_/Q _3947_/S VGND VGND VPWR VPWR _7370_/D sky130_fd_sc_hd__mux2_2
XFILLER_109_216 VGND VGND VPWR VPWR sky130_fd_sc_hd__decap_3
X_6658_ _6663_/A VGND VGND VPWR VPWR _6658_/Y sky130_fd_sc_hd__inv_2
XFILLER_11_11 VGND VGND VPWR VPWR sky130_fd_sc_hd__fill_1
X_5609_ _5609_/A _5622_/B VGND VGND VPWR VPWR _7023_/D sky130_fd_sc_hd__or2_2
XFILLER_3_505 VGND VGND VPWR VPWR sky130_fd_sc_hd__decap_3
X_6589_ _6622_/A VGND VGND VPWR VPWR _6589_/Y sky130_fd_sc_hd__inv_2
XFILLER_2_6 VGND VGND VPWR VPWR sky130_fd_sc_hd__decap_3
XFILLER_3_538 VGND VGND VPWR VPWR sky130_fd_sc_hd__decap_3
XFILLER_105_477 VGND VGND VPWR VPWR sky130_fd_sc_hd__decap_3
XFILLER_78_306 VGND VGND VPWR VPWR sky130_fd_sc_hd__fill_2
XFILLER_78_339 VGND VGND VPWR VPWR sky130_fd_sc_hd__decap_3
XTAP_TAPCELL_ROW_6_321 VGND VPWR sky130_fd_sc_hd__tapvpwrvgnd_1
XFILLER_101_650 VGND VGND VPWR VPWR sky130_fd_sc_hd__decap_3
XFILLER_59_564 VGND VGND VPWR VPWR sky130_fd_sc_hd__decap_3
XFILLER_86_350 VGND VGND VPWR VPWR sky130_fd_sc_hd__decap_3
XFILLER_19_439 VGND VGND VPWR VPWR sky130_fd_sc_hd__decap_3
XFILLER_59_597 VGND VGND VPWR VPWR sky130_fd_sc_hd__decap_3
XFILLER_74_545 VGND VGND VPWR VPWR sky130_fd_sc_hd__decap_3
XFILLER_15_612 VGND VGND VPWR VPWR sky130_fd_sc_hd__decap_3
XFILLER_27_461 VGND VGND VPWR VPWR sky130_fd_sc_hd__decap_3
XFILLER_46_269 VGND VGND VPWR VPWR sky130_fd_sc_hd__decap_3
XFILLER_74_578 VGND VGND VPWR VPWR sky130_fd_sc_hd__decap_3
XFILLER_74_589 VGND VGND VPWR VPWR sky130_fd_sc_hd__decap_3
XFILLER_15_623 VGND VGND VPWR VPWR sky130_fd_sc_hd__decap_3
XFILLER_36_85 VGND VGND VPWR VPWR sky130_fd_sc_hd__decap_3
XFILLER_61_239 VGND VGND VPWR VPWR sky130_fd_sc_hd__decap_3
XTAP_TAPCELL_ROW_68_1070 VGND VPWR sky130_fd_sc_hd__tapvpwrvgnd_1
XFILLER_14_144 VGND VGND VPWR VPWR sky130_fd_sc_hd__decap_3
XFILLER_15_656 VGND VGND VPWR VPWR sky130_fd_sc_hd__decap_3
XFILLER_30_604 VGND VGND VPWR VPWR sky130_fd_sc_hd__decap_3
XFILLER_42_442 VGND VGND VPWR VPWR sky130_fd_sc_hd__decap_3
XFILLER_14_177 VGND VGND VPWR VPWR sky130_fd_sc_hd__decap_3
XFILLER_30_637 VGND VGND VPWR VPWR sky130_fd_sc_hd__decap_3
XFILLER_30_648 VGND VGND VPWR VPWR sky130_fd_sc_hd__decap_3
XFILLER_10_361 VGND VGND VPWR VPWR sky130_fd_sc_hd__decap_3
XFILLER_6_365 VGND VGND VPWR VPWR sky130_fd_sc_hd__decap_3
XFILLER_108_282 VGND VGND VPWR VPWR sky130_fd_sc_hd__decap_3
XFILLER_2_560 VGND VGND VPWR VPWR sky130_fd_sc_hd__decap_3
XFILLER_97_626 VGND VGND VPWR VPWR sky130_fd_sc_hd__decap_3
XFILLER_97_615 VGND VGND VPWR VPWR sky130_fd_sc_hd__fill_1
XFILLER_111_414 VGND VGND VPWR VPWR sky130_fd_sc_hd__decap_3
XFILLER_96_114 VGND VGND VPWR VPWR sky130_fd_sc_hd__decap_3
XFILLER_97_659 VGND VGND VPWR VPWR sky130_fd_sc_hd__decap_3
XFILLER_111_447 VGND VGND VPWR VPWR sky130_fd_sc_hd__fill_1
XFILLER_111_458 VGND VGND VPWR VPWR sky130_fd_sc_hd__decap_3
XFILLER_77_350 VGND VGND VPWR VPWR sky130_fd_sc_hd__decap_3
XFILLER_96_147 VGND VGND VPWR VPWR sky130_fd_sc_hd__decap_3
XFILLER_65_501 VGND VGND VPWR VPWR sky130_fd_sc_hd__decap_3
XFILLER_37_225 VGND VGND VPWR VPWR sky130_fd_sc_hd__decap_3
XFILLER_52_206 VGND VGND VPWR VPWR sky130_fd_sc_hd__fill_1
XFILLER_65_567 VGND VGND VPWR VPWR sky130_fd_sc_hd__decap_3
XFILLER_52_228 VGND VGND VPWR VPWR sky130_fd_sc_hd__fill_2
XFILLER_80_548 VGND VGND VPWR VPWR sky130_fd_sc_hd__decap_3
XFILLER_92_397 VGND VGND VPWR VPWR sky130_fd_sc_hd__decap_3
XFILLER_93_91 VGND VGND VPWR VPWR sky130_fd_sc_hd__fill_2
X_4911_ _6997_/Q _4931_/A VGND VGND VPWR VPWR _4912_/B sky130_fd_sc_hd__nor2_2
XFILLER_33_442 VGND VGND VPWR VPWR sky130_fd_sc_hd__decap_3
XFILLER_21_615 VGND VGND VPWR VPWR sky130_fd_sc_hd__fill_1
XFILLER_21_626 VGND VGND VPWR VPWR sky130_fd_sc_hd__decap_3
XFILLER_60_250 VGND VGND VPWR VPWR sky130_fd_sc_hd__fill_2
X_4842_ _4643_/Y _4841_/Y _4845_/A VGND VGND VPWR VPWR _4842_/X sky130_fd_sc_hd__a21o_2
XFILLER_21_659 VGND VGND VPWR VPWR sky130_fd_sc_hd__decap_3
XFILLER_60_294 VGND VGND VPWR VPWR sky130_fd_sc_hd__fill_1
XTAP_TAPCELL_ROW_31_621 VGND VPWR sky130_fd_sc_hd__tapvpwrvgnd_1
XFILLER_20_169 VGND VGND VPWR VPWR sky130_fd_sc_hd__fill_1
X_6512_ _6644_/A VGND VGND VPWR VPWR _6512_/Y sky130_fd_sc_hd__inv_2
X_3724_ _6828_/Q _3879_/A2 _3879_/B1 _6818_/Q _3723_/X VGND VGND VPWR VPWR _3724_/X
+ sky130_fd_sc_hd__a221o_2
X_6443_ _6602_/A VGND VGND VPWR VPWR _6443_/Y sky130_fd_sc_hd__inv_2
XFILLER_106_208 VGND VGND VPWR VPWR sky130_fd_sc_hd__decap_3
X_6374_ _6602_/A VGND VGND VPWR VPWR _6374_/Y sky130_fd_sc_hd__inv_2
X_3586_ _3591_/A _3591_/B _3591_/C _3586_/D VGND VGND VPWR VPWR _3586_/Y sky130_fd_sc_hd__nor4_2
XFILLER_0_508 VGND VGND VPWR VPWR sky130_fd_sc_hd__decap_3
XFILLER_88_604 VGND VGND VPWR VPWR sky130_fd_sc_hd__decap_3
X_5325_ _5325_/A0 _4964_/X _5340_/S VGND VGND VPWR VPWR _7168_/D sky130_fd_sc_hd__mux2_2
XFILLER_114_296 VGND VGND VPWR VPWR sky130_fd_sc_hd__decap_3
XFILLER_87_136 VGND VGND VPWR VPWR sky130_fd_sc_hd__decap_3
XFILLER_88_637 VGND VGND VPWR VPWR sky130_fd_sc_hd__decap_3
XFILLER_88_648 VGND VGND VPWR VPWR sky130_fd_sc_hd__decap_3
X_5256_ _5256_/A0 _4932_/X _5256_/S VGND VGND VPWR VPWR _7202_/D sky130_fd_sc_hd__mux2_2
XFILLER_87_169 VGND VGND VPWR VPWR sky130_fd_sc_hd__decap_3
X_4207_ _4207_/A _4642_/B VGND VGND VPWR VPWR _4208_/B sky130_fd_sc_hd__and2_2
XFILLER_96_681 VGND VGND VPWR VPWR sky130_fd_sc_hd__decap_3
XFILLER_110_480 VGND VGND VPWR VPWR sky130_fd_sc_hd__decap_3
XFILLER_113_35 VGND VGND VPWR VPWR sky130_fd_sc_hd__decap_3
XFILLER_28_236 VGND VGND VPWR VPWR sky130_fd_sc_hd__decap_3
XFILLER_56_545 VGND VGND VPWR VPWR sky130_fd_sc_hd__fill_2
X_4138_ _4134_/X _4137_/X _4327_/A VGND VGND VPWR VPWR _4642_/B sky130_fd_sc_hd__o21a_2
XTAP_TAPCELL_ROW_39_721 VGND VPWR sky130_fd_sc_hd__tapvpwrvgnd_1
XFILLER_113_57 VGND VGND VPWR VPWR sky130_fd_sc_hd__decap_3
XFILLER_56_567 VGND VGND VPWR VPWR sky130_fd_sc_hd__decap_3
XFILLER_56_589 VGND VGND VPWR VPWR sky130_fd_sc_hd__decap_3
XFILLER_83_375 VGND VGND VPWR VPWR sky130_fd_sc_hd__decap_3
X_4069_ _4744_/B _4069_/B VGND VGND VPWR VPWR _4745_/A sky130_fd_sc_hd__nor2_1
XFILLER_43_228 VGND VGND VPWR VPWR sky130_fd_sc_hd__fill_2
XFILLER_43_239 VGND VGND VPWR VPWR sky130_fd_sc_hd__decap_3
XTAP_TAPCELL_ROW_104_1502 VGND VPWR sky130_fd_sc_hd__tapvpwrvgnd_1
XFILLER_12_604 VGND VGND VPWR VPWR sky130_fd_sc_hd__decap_3
XFILLER_12_637 VGND VGND VPWR VPWR sky130_fd_sc_hd__decap_3
XFILLER_24_464 VGND VGND VPWR VPWR sky130_fd_sc_hd__decap_3
XFILLER_24_475 VGND VGND VPWR VPWR sky130_fd_sc_hd__fill_1
XFILLER_51_272 VGND VGND VPWR VPWR sky130_fd_sc_hd__decap_3
XFILLER_12_648 VGND VGND VPWR VPWR sky130_fd_sc_hd__decap_3
XFILLER_8_619 VGND VGND VPWR VPWR sky130_fd_sc_hd__decap_3
XFILLER_20_681 VGND VGND VPWR VPWR sky130_fd_sc_hd__decap_3
XFILLER_3_335 VGND VGND VPWR VPWR sky130_fd_sc_hd__fill_1
XTAP_TAPCELL_ROW_115_1631 VGND VPWR sky130_fd_sc_hd__tapvpwrvgnd_1
XFILLER_0_3 VGND VGND VPWR VPWR sky130_fd_sc_hd__decap_3
XFILLER_79_615 VGND VGND VPWR VPWR sky130_fd_sc_hd__fill_1
XFILLER_105_296 VGND VGND VPWR VPWR sky130_fd_sc_hd__decap_3
XFILLER_78_103 VGND VGND VPWR VPWR sky130_fd_sc_hd__decap_3
XFILLER_79_626 VGND VGND VPWR VPWR sky130_fd_sc_hd__decap_3
XFILLER_79_659 VGND VGND VPWR VPWR sky130_fd_sc_hd__decap_3
XFILLER_66_309 VGND VGND VPWR VPWR sky130_fd_sc_hd__decap_3
XFILLER_78_136 VGND VGND VPWR VPWR sky130_fd_sc_hd__decap_3
XFILLER_94_607 VGND VGND VPWR VPWR sky130_fd_sc_hd__decap_3
XFILLER_93_106 VGND VGND VPWR VPWR sky130_fd_sc_hd__decap_3
XFILLER_101_480 VGND VGND VPWR VPWR sky130_fd_sc_hd__decap_3
XFILLER_19_225 VGND VGND VPWR VPWR sky130_fd_sc_hd__decap_3
XFILLER_74_342 VGND VGND VPWR VPWR sky130_fd_sc_hd__decap_3
XFILLER_47_567 VGND VGND VPWR VPWR sky130_fd_sc_hd__decap_3
XFILLER_34_217 VGND VGND VPWR VPWR sky130_fd_sc_hd__decap_3
XFILLER_62_548 VGND VGND VPWR VPWR sky130_fd_sc_hd__decap_3
XTAP_TAPCELL_ROW_17_459 VGND VPWR sky130_fd_sc_hd__tapvpwrvgnd_1
XFILLER_70_570 VGND VGND VPWR VPWR sky130_fd_sc_hd__decap_3
XFILLER_42_294 VGND VGND VPWR VPWR sky130_fd_sc_hd__decap_3
XFILLER_70_592 VGND VGND VPWR VPWR sky130_fd_sc_hd__decap_3
XFILLER_30_467 VGND VGND VPWR VPWR sky130_fd_sc_hd__decap_3
XPHY_EDGE_ROW_7_Left_124 VGND VGND VPWR VPWR sky130_fd_sc_hd__decap_3
XFILLER_7_641 VGND VGND VPWR VPWR sky130_fd_sc_hd__decap_3
Xwire550 _3749_/Y VGND VGND VPWR VPWR wire550/X sky130_fd_sc_hd__clkbuf_2
XFILLER_6_151 VGND VGND VPWR VPWR sky130_fd_sc_hd__decap_3
XFILLER_7_685 VGND VGND VPWR VPWR sky130_fd_sc_hd__decap_3
Xhold608 _6771_/Q VGND VGND VPWR VPWR _6771_/D sky130_fd_sc_hd__dlygate4sd3_1
XFILLER_109_591 VGND VGND VPWR VPWR sky130_fd_sc_hd__decap_3
Xhold619 _6738_/Q VGND VGND VPWR VPWR _6738_/D sky130_fd_sc_hd__dlygate4sd3_1
X_3440_ _7250_/Q _4601_/S _3434_/X _3439_/X VGND VGND VPWR VPWR _3440_/X sky130_fd_sc_hd__a211o_2
X_3371_ _3371_/A _5118_/D _5118_/A _3331_/B VGND VGND VPWR VPWR _3371_/Y sky130_fd_sc_hd__nor4bb_1
XFILLER_111_200 VGND VGND VPWR VPWR sky130_fd_sc_hd__decap_3
XFILLER_33_3 VGND VGND VPWR VPWR sky130_fd_sc_hd__fill_2
XFILLER_88_80 VGND VGND VPWR VPWR sky130_fd_sc_hd__decap_3
XFILLER_88_91 VGND VGND VPWR VPWR sky130_fd_sc_hd__decap_3
X_5110_ _3610_/A _3603_/Y _4292_/C VGND VGND VPWR VPWR _5110_/Y sky130_fd_sc_hd__a21oi_2
XTAP_TAPCELL_ROW_90_1336 VGND VPWR sky130_fd_sc_hd__tapvpwrvgnd_1
XFILLER_111_233 VGND VGND VPWR VPWR sky130_fd_sc_hd__decap_3
X_5041_ _5041_/A0 _5040_/X _5108_/S VGND VGND VPWR VPWR _7259_/D sky130_fd_sc_hd__mux2_2
XFILLER_78_681 VGND VGND VPWR VPWR sky130_fd_sc_hd__decap_3
XFILLER_85_629 VGND VGND VPWR VPWR sky130_fd_sc_hd__decap_3
XFILLER_84_139 VGND VGND VPWR VPWR sky130_fd_sc_hd__fill_1
XFILLER_38_578 VGND VGND VPWR VPWR sky130_fd_sc_hd__decap_3
XFILLER_38_589 VGND VGND VPWR VPWR sky130_fd_sc_hd__decap_3
XFILLER_93_662 VGND VGND VPWR VPWR sky130_fd_sc_hd__decap_3
XFILLER_93_673 VGND VGND VPWR VPWR sky130_fd_sc_hd__decap_3
XFILLER_25_228 VGND VGND VPWR VPWR sky130_fd_sc_hd__decap_3
XFILLER_92_194 VGND VGND VPWR VPWR sky130_fd_sc_hd__fill_2
X_6992_ _7144_/CLK _6992_/D _6272_/Y VGND VGND VPWR VPWR _6992_/Q sky130_fd_sc_hd__dfrtp_2
XFILLER_33_261 VGND VGND VPWR VPWR sky130_fd_sc_hd__decap_3
XFILLER_40_209 VGND VGND VPWR VPWR sky130_fd_sc_hd__decap_3
XFILLER_61_570 VGND VGND VPWR VPWR sky130_fd_sc_hd__decap_3
X_4825_ _7001_/Q _4825_/B VGND VGND VPWR VPWR _4826_/B sky130_fd_sc_hd__nor2_2
XFILLER_107_517 VGND VGND VPWR VPWR sky130_fd_sc_hd__decap_3
X_4687_ _7001_/Q _4687_/B VGND VGND VPWR VPWR _4834_/A sky130_fd_sc_hd__and2_2
X_3707_ _6937_/Q _3768_/A2 _3902_/B1 _6889_/Q VGND VGND VPWR VPWR _3707_/X sky130_fd_sc_hd__a22o_2
XFILLER_104_9 VGND VGND VPWR VPWR sky130_fd_sc_hd__decap_3
XFILLER_108_24 VGND VGND VPWR VPWR sky130_fd_sc_hd__decap_3
XFILLER_108_35 VGND VGND VPWR VPWR sky130_fd_sc_hd__decap_3
X_6426_ _6680_/A VGND VGND VPWR VPWR _6426_/Y sky130_fd_sc_hd__inv_2
X_3638_ _3635_/A _3521_/Y _3547_/A VGND VGND VPWR VPWR _3638_/X sky130_fd_sc_hd__a21bo_2
XFILLER_115_550 VGND VGND VPWR VPWR sky130_fd_sc_hd__decap_3
XFILLER_115_561 VGND VGND VPWR VPWR sky130_fd_sc_hd__decap_3
X_6357_ _6364_/A VGND VGND VPWR VPWR _6357_/Y sky130_fd_sc_hd__inv_2
X_3569_ _7285_/Q _5159_/S _3567_/X _3568_/X VGND VGND VPWR VPWR _3569_/X sky130_fd_sc_hd__a211o_2
XFILLER_115_594 VGND VGND VPWR VPWR sky130_fd_sc_hd__decap_3
X_5308_ _5308_/A0 _4822_/X _5315_/S VGND VGND VPWR VPWR _7176_/D sky130_fd_sc_hd__mux2_2
XFILLER_102_244 VGND VGND VPWR VPWR sky130_fd_sc_hd__decap_3
XFILLER_76_607 VGND VGND VPWR VPWR sky130_fd_sc_hd__decap_3
XFILLER_88_456 VGND VGND VPWR VPWR sky130_fd_sc_hd__fill_1
X_6288_ _6288_/A VGND VGND VPWR VPWR _6288_/Y sky130_fd_sc_hd__inv_2
XFILLER_48_309 VGND VGND VPWR VPWR sky130_fd_sc_hd__decap_3
X_5239_ hold950/X _5238_/X _4766_/A VGND VGND VPWR VPWR _7211_/D sky130_fd_sc_hd__a21o_2
XTAP_TAPCELL_ROW_110_1572 VGND VPWR sky130_fd_sc_hd__tapvpwrvgnd_1
XFILLER_68_180 VGND VGND VPWR VPWR sky130_fd_sc_hd__decap_3
XFILLER_84_640 VGND VGND VPWR VPWR sky130_fd_sc_hd__decap_3
XFILLER_29_567 VGND VGND VPWR VPWR sky130_fd_sc_hd__decap_3
XFILLER_56_353 VGND VGND VPWR VPWR sky130_fd_sc_hd__decap_3
XFILLER_84_651 VGND VGND VPWR VPWR sky130_fd_sc_hd__decap_3
XFILLER_71_301 VGND VGND VPWR VPWR sky130_fd_sc_hd__decap_3
XFILLER_71_334 VGND VGND VPWR VPWR sky130_fd_sc_hd__fill_2
XFILLER_84_684 VGND VGND VPWR VPWR sky130_fd_sc_hd__decap_3
XTAP_TAPCELL_ROW_14_418 VGND VPWR sky130_fd_sc_hd__tapvpwrvgnd_1
XFILLER_24_283 VGND VGND VPWR VPWR sky130_fd_sc_hd__decap_3
XFILLER_52_592 VGND VGND VPWR VPWR sky130_fd_sc_hd__decap_3
XFILLER_12_467 VGND VGND VPWR VPWR sky130_fd_sc_hd__decap_3
XFILLER_8_427 VGND VGND VPWR VPWR sky130_fd_sc_hd__decap_3
XFILLER_4_622 VGND VGND VPWR VPWR sky130_fd_sc_hd__decap_3
XFILLER_3_121 VGND VGND VPWR VPWR sky130_fd_sc_hd__decap_3
XFILLER_4_666 VGND VGND VPWR VPWR sky130_fd_sc_hd__decap_3
XFILLER_106_572 VGND VGND VPWR VPWR sky130_fd_sc_hd__decap_3
XFILLER_58_83 VGND VGND VPWR VPWR sky130_fd_sc_hd__fill_1
XFILLER_67_629 VGND VGND VPWR VPWR sky130_fd_sc_hd__decap_3
XFILLER_47_320 VGND VGND VPWR VPWR sky130_fd_sc_hd__decap_3
XFILLER_75_662 VGND VGND VPWR VPWR sky130_fd_sc_hd__decap_3
XFILLER_75_673 VGND VGND VPWR VPWR sky130_fd_sc_hd__decap_3
XFILLER_74_183 VGND VGND VPWR VPWR sky130_fd_sc_hd__decap_3
XFILLER_90_610 VGND VGND VPWR VPWR sky130_fd_sc_hd__decap_3
XFILLER_74_71 VGND VGND VPWR VPWR sky130_fd_sc_hd__decap_3
XFILLER_90_643 VGND VGND VPWR VPWR sky130_fd_sc_hd__fill_1
XFILLER_90_654 VGND VGND VPWR VPWR sky130_fd_sc_hd__decap_3
XFILLER_43_570 VGND VGND VPWR VPWR sky130_fd_sc_hd__decap_3
XFILLER_90_687 VGND VGND VPWR VPWR sky130_fd_sc_hd__decap_3
XFILLER_30_253 VGND VGND VPWR VPWR sky130_fd_sc_hd__decap_3
XFILLER_90_70 VGND VGND VPWR VPWR sky130_fd_sc_hd__fill_1
X_4610_ _4610_/A _4762_/B VGND VGND VPWR VPWR _4611_/A sky130_fd_sc_hd__nand2_2
XFILLER_30_286 VGND VGND VPWR VPWR sky130_fd_sc_hd__fill_2
XFILLER_7_482 VGND VGND VPWR VPWR sky130_fd_sc_hd__decap_3
X_7260_ _7362_/CLK _7260_/D _6540_/Y VGND VGND VPWR VPWR _7260_/Q sky130_fd_sc_hd__dfrtp_2
X_7191_ _7344_/CLK _7191_/D _6471_/Y VGND VGND VPWR VPWR _7191_/Q sky130_fd_sc_hd__dfrtp_2
X_3423_ _3874_/A _3442_/B _5699_/S VGND VGND VPWR VPWR _3424_/S sky130_fd_sc_hd__and3_4
XFILLER_112_531 VGND VGND VPWR VPWR sky130_fd_sc_hd__fill_1
XFILLER_112_542 VGND VGND VPWR VPWR sky130_fd_sc_hd__decap_3
XFILLER_58_607 VGND VGND VPWR VPWR sky130_fd_sc_hd__decap_3
X_3354_ _3371_/A _5668_/A _3328_/B _3561_/B VGND VGND VPWR VPWR _3354_/X sky130_fd_sc_hd__a211o_2
XFILLER_112_575 VGND VGND VPWR VPWR sky130_fd_sc_hd__decap_3
XFILLER_57_106 VGND VGND VPWR VPWR sky130_fd_sc_hd__decap_3
XFILLER_85_426 VGND VGND VPWR VPWR sky130_fd_sc_hd__decap_3
Xhold1105 _7207_/Q VGND VGND VPWR VPWR _5245_/A0 sky130_fd_sc_hd__dlygate4sd3_1
XFILLER_66_640 VGND VGND VPWR VPWR sky130_fd_sc_hd__decap_3
Xhold1116 _7249_/Q VGND VGND VPWR VPWR _5142_/A0 sky130_fd_sc_hd__dlygate4sd3_1
Xhold1127 _7139_/Q VGND VGND VPWR VPWR _5388_/A0 sky130_fd_sc_hd__dlygate4sd3_1
Xhold1138 _7340_/Q VGND VGND VPWR VPWR _4478_/A0 sky130_fd_sc_hd__dlygate4sd3_1
Xhold1149 _7328_/Q VGND VGND VPWR VPWR _4503_/A0 sky130_fd_sc_hd__dlygate4sd3_1
X_5024_ _3833_/S _3832_/X _5015_/X _5023_/Y VGND VGND VPWR VPWR _5024_/X sky130_fd_sc_hd__a211o_2
XFILLER_66_651 VGND VGND VPWR VPWR sky130_fd_sc_hd__decap_3
XFILLER_72_109 VGND VGND VPWR VPWR sky130_fd_sc_hd__decap_3
XFILLER_66_684 VGND VGND VPWR VPWR sky130_fd_sc_hd__decap_3
XFILLER_81_632 VGND VGND VPWR VPWR sky130_fd_sc_hd__decap_3
XFILLER_26_559 VGND VGND VPWR VPWR sky130_fd_sc_hd__decap_3
XFILLER_81_665 VGND VGND VPWR VPWR sky130_fd_sc_hd__decap_3
X_6975_ clkload7/A _6975_/D VGND VGND VPWR VPWR _6975_/Q sky130_fd_sc_hd__dfxtp_2
XFILLER_53_389 VGND VGND VPWR VPWR sky130_fd_sc_hd__decap_3
XFILLER_81_676 VGND VGND VPWR VPWR sky130_fd_sc_hd__decap_3
XFILLER_110_47 VGND VGND VPWR VPWR sky130_fd_sc_hd__decap_3
XFILLER_21_220 VGND VGND VPWR VPWR sky130_fd_sc_hd__decap_3
XFILLER_34_592 VGND VGND VPWR VPWR sky130_fd_sc_hd__decap_3
XFILLER_80_186 VGND VGND VPWR VPWR sky130_fd_sc_hd__decap_3
XFILLER_80_197 VGND VGND VPWR VPWR sky130_fd_sc_hd__fill_1
XFILLER_21_231 VGND VGND VPWR VPWR sky130_fd_sc_hd__decap_3
XFILLER_21_264 VGND VGND VPWR VPWR sky130_fd_sc_hd__fill_2
XFILLER_70_29 VGND VGND VPWR VPWR sky130_fd_sc_hd__decap_3
XFILLER_107_303 VGND VGND VPWR VPWR sky130_fd_sc_hd__decap_3
X_4739_ _4762_/A _4762_/B _4765_/B _4610_/A VGND VGND VPWR VPWR _4739_/Y sky130_fd_sc_hd__a211oi_2
XFILLER_107_325 VGND VGND VPWR VPWR sky130_fd_sc_hd__decap_3
XFILLER_107_358 VGND VGND VPWR VPWR sky130_fd_sc_hd__decap_3
X_6409_ _6638_/A VGND VGND VPWR VPWR _6409_/Y sky130_fd_sc_hd__inv_2
XTAP_TAPCELL_ROW_112_1601 VGND VPWR sky130_fd_sc_hd__tapvpwrvgnd_1
XFILLER_0_102 VGND VGND VPWR VPWR sky130_fd_sc_hd__fill_2
X_7389_ _7392_/CLK _7389_/D _6669_/Y VGND VGND VPWR VPWR _7389_/Q sky130_fd_sc_hd__dfrtp_2
Xhold972 _7033_/Q VGND VGND VPWR VPWR _5589_/A sky130_fd_sc_hd__dlygate4sd3_1
Xhold961 _7027_/Q VGND VGND VPWR VPWR _5600_/A sky130_fd_sc_hd__dlygate4sd3_1
Xhold950 _7211_/Q VGND VGND VPWR VPWR hold950/X sky130_fd_sc_hd__dlygate4sd3_1
XFILLER_0_113 VGND VGND VPWR VPWR sky130_fd_sc_hd__fill_2
XFILLER_103_520 VGND VGND VPWR VPWR sky130_fd_sc_hd__decap_3
XFILLER_103_553 VGND VGND VPWR VPWR sky130_fd_sc_hd__decap_3
XFILLER_1_647 VGND VGND VPWR VPWR sky130_fd_sc_hd__decap_3
XFILLER_88_220 VGND VGND VPWR VPWR sky130_fd_sc_hd__decap_3
Xhold994 _7239_/Q VGND VGND VPWR VPWR _5177_/A sky130_fd_sc_hd__dlygate4sd3_1
Xhold983 _7026_/Q VGND VGND VPWR VPWR _5602_/A sky130_fd_sc_hd__dlygate4sd3_1
XFILLER_103_564 VGND VGND VPWR VPWR sky130_fd_sc_hd__decap_3
XFILLER_48_106 VGND VGND VPWR VPWR sky130_fd_sc_hd__fill_2
XFILLER_49_629 VGND VGND VPWR VPWR sky130_fd_sc_hd__decap_3
XFILLER_88_253 VGND VGND VPWR VPWR sky130_fd_sc_hd__decap_3
XFILLER_95_26 VGND VGND VPWR VPWR sky130_fd_sc_hd__decap_3
XFILLER_103_597 VGND VGND VPWR VPWR sky130_fd_sc_hd__decap_3
XFILLER_48_139 VGND VGND VPWR VPWR sky130_fd_sc_hd__fill_1
XFILLER_29_331 VGND VGND VPWR VPWR sky130_fd_sc_hd__decap_3
XFILLER_29_364 VGND VGND VPWR VPWR sky130_fd_sc_hd__decap_3
XFILLER_57_662 VGND VGND VPWR VPWR sky130_fd_sc_hd__decap_3
XFILLER_57_673 VGND VGND VPWR VPWR sky130_fd_sc_hd__decap_3
XTAP_TAPCELL_ROW_47_819 VGND VPWR sky130_fd_sc_hd__tapvpwrvgnd_1
XFILLER_17_526 VGND VGND VPWR VPWR sky130_fd_sc_hd__decap_3
XFILLER_44_312 VGND VGND VPWR VPWR sky130_fd_sc_hd__decap_3
XFILLER_72_610 VGND VGND VPWR VPWR sky130_fd_sc_hd__decap_3
XFILLER_17_559 VGND VGND VPWR VPWR sky130_fd_sc_hd__fill_1
XFILLER_71_131 VGND VGND VPWR VPWR sky130_fd_sc_hd__decap_3
XFILLER_72_643 VGND VGND VPWR VPWR sky130_fd_sc_hd__fill_1
XFILLER_72_654 VGND VGND VPWR VPWR sky130_fd_sc_hd__decap_3
XPHY_EDGE_ROW_88_Left_205 VGND VGND VPWR VPWR sky130_fd_sc_hd__decap_3
XFILLER_25_570 VGND VGND VPWR VPWR sky130_fd_sc_hd__decap_3
XFILLER_44_378 VGND VGND VPWR VPWR sky130_fd_sc_hd__fill_1
XFILLER_44_389 VGND VGND VPWR VPWR sky130_fd_sc_hd__fill_2
XFILLER_71_175 VGND VGND VPWR VPWR sky130_fd_sc_hd__decap_3
XFILLER_72_687 VGND VGND VPWR VPWR sky130_fd_sc_hd__decap_3
XTAP_TAPCELL_ROW_27_576 VGND VPWR sky130_fd_sc_hd__tapvpwrvgnd_1
XFILLER_71_186 VGND VGND VPWR VPWR sky130_fd_sc_hd__decap_3
XFILLER_12_242 VGND VGND VPWR VPWR sky130_fd_sc_hd__decap_3
XFILLER_12_253 VGND VGND VPWR VPWR sky130_fd_sc_hd__fill_1
XFILLER_40_584 VGND VGND VPWR VPWR sky130_fd_sc_hd__decap_3
XFILLER_40_595 VGND VGND VPWR VPWR sky130_fd_sc_hd__decap_3
XPHY_EDGE_ROW_97_Left_214 VGND VGND VPWR VPWR sky130_fd_sc_hd__decap_3
XFILLER_113_306 VGND VGND VPWR VPWR sky130_fd_sc_hd__decap_3
XFILLER_4_463 VGND VGND VPWR VPWR sky130_fd_sc_hd__decap_3
XTAP_TAPCELL_ROW_74_1139 VGND VPWR sky130_fd_sc_hd__tapvpwrvgnd_1
XFILLER_99_529 VGND VGND VPWR VPWR sky130_fd_sc_hd__decap_3
XFILLER_69_60 VGND VGND VPWR VPWR sky130_fd_sc_hd__decap_3
XFILLER_79_231 VGND VGND VPWR VPWR sky130_fd_sc_hd__decap_3
XFILLER_67_404 VGND VGND VPWR VPWR sky130_fd_sc_hd__decap_3
XFILLER_79_253 VGND VGND VPWR VPWR sky130_fd_sc_hd__decap_3
XFILLER_79_275 VGND VGND VPWR VPWR sky130_fd_sc_hd__decap_3
XFILLER_67_437 VGND VGND VPWR VPWR sky130_fd_sc_hd__decap_3
XFILLER_94_234 VGND VGND VPWR VPWR sky130_fd_sc_hd__decap_3
XFILLER_48_640 VGND VGND VPWR VPWR sky130_fd_sc_hd__decap_3
XFILLER_48_651 VGND VGND VPWR VPWR sky130_fd_sc_hd__decap_3
XFILLER_82_418 VGND VGND VPWR VPWR sky130_fd_sc_hd__fill_2
XFILLER_94_256 VGND VGND VPWR VPWR sky130_fd_sc_hd__decap_3
XFILLER_47_172 VGND VGND VPWR VPWR sky130_fd_sc_hd__decap_3
XFILLER_48_684 VGND VGND VPWR VPWR sky130_fd_sc_hd__decap_3
XFILLER_63_632 VGND VGND VPWR VPWR sky130_fd_sc_hd__decap_3
XFILLER_47_183 VGND VGND VPWR VPWR sky130_fd_sc_hd__fill_1
XFILLER_63_665 VGND VGND VPWR VPWR sky130_fd_sc_hd__decap_3
XFILLER_50_315 VGND VGND VPWR VPWR sky130_fd_sc_hd__fill_1
XFILLER_63_676 VGND VGND VPWR VPWR sky130_fd_sc_hd__decap_3
XFILLER_90_484 VGND VGND VPWR VPWR sky130_fd_sc_hd__decap_3
X_6760_ _6959_/CLK _6760_/D VGND VGND VPWR VPWR _6760_/Q sky130_fd_sc_hd__dfxtp_2
XTAP_TAPCELL_ROW_85_1268 VGND VPWR sky130_fd_sc_hd__tapvpwrvgnd_1
XFILLER_16_581 VGND VGND VPWR VPWR sky130_fd_sc_hd__decap_3
XFILLER_16_592 VGND VGND VPWR VPWR sky130_fd_sc_hd__decap_3
XFILLER_50_337 VGND VGND VPWR VPWR sky130_fd_sc_hd__decap_3
XFILLER_62_197 VGND VGND VPWR VPWR sky130_fd_sc_hd__decap_3
X_6691_ _7311_/CLK _6691_/D VGND VGND VPWR VPWR _6691_/Q sky130_fd_sc_hd__dfxtp_2
XFILLER_31_573 VGND VGND VPWR VPWR sky130_fd_sc_hd__decap_3
X_5642_ _5642_/A _5642_/B VGND VGND VPWR VPWR _5643_/A sky130_fd_sc_hd__or2_2
X_5573_ hold973/X _5593_/B _4975_/Y VGND VGND VPWR VPWR _7044_/D sky130_fd_sc_hd__o21a_2
X_7312_ _7344_/CLK _7312_/D _6592_/Y VGND VGND VPWR VPWR _7312_/Q sky130_fd_sc_hd__dfrtp_2
X_4524_ _4524_/A0 _7285_/Q _4528_/B VGND VGND VPWR VPWR _7317_/D sky130_fd_sc_hd__mux2_2
XFILLER_116_155 VGND VGND VPWR VPWR sky130_fd_sc_hd__decap_3
X_7243_ _7307_/CLK _7243_/D _6523_/Y VGND VGND VPWR VPWR _7243_/Q sky130_fd_sc_hd__dfrtp_2
X_4455_ _4610_/A _4081_/X _4082_/X _4454_/X VGND VGND VPWR VPWR _4720_/B sky130_fd_sc_hd__o211a_2
XFILLER_104_339 VGND VGND VPWR VPWR sky130_fd_sc_hd__decap_3
X_7174_ _7395_/CLK _7174_/D _6454_/Y VGND VGND VPWR VPWR _7174_/Q sky130_fd_sc_hd__dfrtp_2
X_4386_ _7305_/Q _4488_/S _4437_/B1 _7369_/Q _4429_/C1 VGND VGND VPWR VPWR _4386_/X
+ sky130_fd_sc_hd__a221o_2
X_3406_ _3409_/D VGND VGND VPWR VPWR _3417_/C sky130_fd_sc_hd__inv_4
XFILLER_98_551 VGND VGND VPWR VPWR sky130_fd_sc_hd__decap_3
XFILLER_100_501 VGND VGND VPWR VPWR sky130_fd_sc_hd__decap_3
XFILLER_98_584 VGND VGND VPWR VPWR sky130_fd_sc_hd__decap_3
XFILLER_100_545 VGND VGND VPWR VPWR sky130_fd_sc_hd__decap_3
XFILLER_105_36 VGND VGND VPWR VPWR sky130_fd_sc_hd__decap_3
XFILLER_112_394 VGND VGND VPWR VPWR sky130_fd_sc_hd__decap_3
XFILLER_85_223 VGND VGND VPWR VPWR sky130_fd_sc_hd__fill_1
XFILLER_98_595 VGND VGND VPWR VPWR sky130_fd_sc_hd__decap_3
XFILLER_100_578 VGND VGND VPWR VPWR sky130_fd_sc_hd__decap_3
XFILLER_105_69 VGND VGND VPWR VPWR sky130_fd_sc_hd__decap_3
XFILLER_39_662 VGND VGND VPWR VPWR sky130_fd_sc_hd__decap_3
XFILLER_65_18 VGND VGND VPWR VPWR sky130_fd_sc_hd__decap_3
XFILLER_100_589 VGND VGND VPWR VPWR sky130_fd_sc_hd__decap_3
XFILLER_26_312 VGND VGND VPWR VPWR sky130_fd_sc_hd__decap_3
XFILLER_38_172 VGND VGND VPWR VPWR sky130_fd_sc_hd__decap_3
XFILLER_39_673 VGND VGND VPWR VPWR sky130_fd_sc_hd__decap_3
XFILLER_54_610 VGND VGND VPWR VPWR sky130_fd_sc_hd__decap_3
X_5007_ _5002_/Y _5003_/X _5004_/X _5005_/Y _5006_/X VGND VGND VPWR VPWR _5662_/A
+ sky130_fd_sc_hd__a221o_2
XFILLER_26_356 VGND VGND VPWR VPWR sky130_fd_sc_hd__decap_3
XFILLER_54_643 VGND VGND VPWR VPWR sky130_fd_sc_hd__fill_1
XFILLER_54_654 VGND VGND VPWR VPWR sky130_fd_sc_hd__decap_3
XFILLER_14_529 VGND VGND VPWR VPWR sky130_fd_sc_hd__decap_3
XFILLER_41_315 VGND VGND VPWR VPWR sky130_fd_sc_hd__decap_3
XFILLER_53_175 VGND VGND VPWR VPWR sky130_fd_sc_hd__decap_3
XFILLER_54_687 VGND VGND VPWR VPWR sky130_fd_sc_hd__decap_3
XFILLER_41_348 VGND VGND VPWR VPWR sky130_fd_sc_hd__decap_3
X_6958_ clkload8/A _6958_/D VGND VGND VPWR VPWR _6958_/Q sky130_fd_sc_hd__dfxtp_2
XTAP_TAPCELL_ROW_24_535 VGND VPWR sky130_fd_sc_hd__tapvpwrvgnd_1
XFILLER_22_562 VGND VGND VPWR VPWR sky130_fd_sc_hd__decap_3
X_6889_ _6941_/CLK _6889_/D VGND VGND VPWR VPWR _6889_/Q sky130_fd_sc_hd__dfxtp_2
XTAP_TAPCELL_ROW_52_877 VGND VPWR sky130_fd_sc_hd__tapvpwrvgnd_1
XFILLER_22_595 VGND VGND VPWR VPWR sky130_fd_sc_hd__decap_3
XFILLER_108_601 VGND VGND VPWR VPWR sky130_fd_sc_hd__decap_3
XFILLER_107_111 VGND VGND VPWR VPWR sky130_fd_sc_hd__fill_1
XFILLER_108_634 VGND VGND VPWR VPWR sky130_fd_sc_hd__decap_3
XFILLER_108_645 VGND VGND VPWR VPWR sky130_fd_sc_hd__decap_3
XFILLER_5_205 VGND VGND VPWR VPWR sky130_fd_sc_hd__decap_3
XFILLER_107_155 VGND VGND VPWR VPWR sky130_fd_sc_hd__decap_3
XFILLER_108_678 VGND VGND VPWR VPWR sky130_fd_sc_hd__decap_3
XFILLER_100_3 VGND VGND VPWR VPWR sky130_fd_sc_hd__decap_3
Xhold780 _6829_/Q VGND VGND VPWR VPWR _6829_/D sky130_fd_sc_hd__dlygate4sd3_1
Xhold791 _6784_/Q VGND VGND VPWR VPWR _6784_/D sky130_fd_sc_hd__dlygate4sd3_1
XFILLER_110_309 VGND VGND VPWR VPWR sky130_fd_sc_hd__fill_1
XFILLER_1_466 VGND VGND VPWR VPWR sky130_fd_sc_hd__decap_3
XFILLER_89_573 VGND VGND VPWR VPWR sky130_fd_sc_hd__decap_3
XFILLER_103_372 VGND VGND VPWR VPWR sky130_fd_sc_hd__decap_3
XFILLER_1_499 VGND VGND VPWR VPWR sky130_fd_sc_hd__decap_3
XFILLER_76_245 VGND VGND VPWR VPWR sky130_fd_sc_hd__decap_3
XFILLER_76_256 VGND VGND VPWR VPWR sky130_fd_sc_hd__fill_2
XFILLER_29_161 VGND VGND VPWR VPWR sky130_fd_sc_hd__decap_3
XFILLER_64_418 VGND VGND VPWR VPWR sky130_fd_sc_hd__fill_2
XFILLER_76_278 VGND VGND VPWR VPWR sky130_fd_sc_hd__fill_1
XFILLER_76_289 VGND VGND VPWR VPWR sky130_fd_sc_hd__decap_3
XFILLER_29_183 VGND VGND VPWR VPWR sky130_fd_sc_hd__fill_1
XFILLER_45_632 VGND VGND VPWR VPWR sky130_fd_sc_hd__decap_3
XFILLER_91_237 VGND VGND VPWR VPWR sky130_fd_sc_hd__fill_1
XFILLER_17_367 VGND VGND VPWR VPWR sky130_fd_sc_hd__decap_3
XFILLER_17_378 VGND VGND VPWR VPWR sky130_fd_sc_hd__fill_2
XFILLER_17_389 VGND VGND VPWR VPWR sky130_fd_sc_hd__decap_3
XFILLER_32_304 VGND VGND VPWR VPWR sky130_fd_sc_hd__decap_3
XFILLER_45_665 VGND VGND VPWR VPWR sky130_fd_sc_hd__decap_3
XFILLER_45_676 VGND VGND VPWR VPWR sky130_fd_sc_hd__decap_3
XFILLER_60_613 VGND VGND VPWR VPWR sky130_fd_sc_hd__decap_3
XFILLER_44_186 VGND VGND VPWR VPWR sky130_fd_sc_hd__decap_3
XFILLER_44_197 VGND VGND VPWR VPWR sky130_fd_sc_hd__fill_1
XFILLER_60_657 VGND VGND VPWR VPWR sky130_fd_sc_hd__decap_3
XFILLER_13_540 VGND VGND VPWR VPWR sky130_fd_sc_hd__decap_3
XFILLER_13_573 VGND VGND VPWR VPWR sky130_fd_sc_hd__decap_3
XFILLER_9_544 VGND VGND VPWR VPWR sky130_fd_sc_hd__decap_3
XFILLER_9_511 VGND VGND VPWR VPWR sky130_fd_sc_hd__decap_3
XFILLER_65_6 VGND VGND VPWR VPWR sky130_fd_sc_hd__decap_3
XFILLER_9_588 VGND VGND VPWR VPWR sky130_fd_sc_hd__decap_3
XFILLER_114_604 VGND VGND VPWR VPWR sky130_fd_sc_hd__decap_3
XFILLER_114_637 VGND VGND VPWR VPWR sky130_fd_sc_hd__decap_3
XFILLER_99_304 VGND VGND VPWR VPWR sky130_fd_sc_hd__decap_3
XFILLER_114_648 VGND VGND VPWR VPWR sky130_fd_sc_hd__decap_3
XFILLER_4_282 VGND VGND VPWR VPWR sky130_fd_sc_hd__decap_3
X_4240_ _4628_/A _4629_/B VGND VGND VPWR VPWR _4241_/B sky130_fd_sc_hd__and2_2
XFILLER_99_337 VGND VGND VPWR VPWR sky130_fd_sc_hd__decap_3
X_4171_ _4203_/A _4203_/B _4202_/A VGND VGND VPWR VPWR _4379_/B sky130_fd_sc_hd__a21oi_2
XFILLER_95_532 VGND VGND VPWR VPWR sky130_fd_sc_hd__decap_3
XFILLER_67_256 VGND VGND VPWR VPWR sky130_fd_sc_hd__decap_3
XFILLER_95_576 VGND VGND VPWR VPWR sky130_fd_sc_hd__decap_3
XFILLER_36_610 VGND VGND VPWR VPWR sky130_fd_sc_hd__decap_3
XFILLER_36_643 VGND VGND VPWR VPWR sky130_fd_sc_hd__fill_1
XFILLER_36_654 VGND VGND VPWR VPWR sky130_fd_sc_hd__decap_3
XFILLER_82_248 VGND VGND VPWR VPWR sky130_fd_sc_hd__decap_3
XFILLER_35_153 VGND VGND VPWR VPWR sky130_fd_sc_hd__fill_2
XFILLER_35_164 VGND VGND VPWR VPWR sky130_fd_sc_hd__decap_3
XFILLER_36_687 VGND VGND VPWR VPWR sky130_fd_sc_hd__decap_3
Xplace440 _4667_/B VGND VGND VPWR VPWR _5634_/B sky130_fd_sc_hd__buf_2
X_6812_ _6970_/CLK _6812_/D VGND VGND VPWR VPWR _6812_/Q sky130_fd_sc_hd__dfxtp_2
XFILLER_23_337 VGND VGND VPWR VPWR sky130_fd_sc_hd__fill_1
XFILLER_51_635 VGND VGND VPWR VPWR sky130_fd_sc_hd__decap_3
Xplace451 _6982_/Q VGND VGND VPWR VPWR _5129_/A sky130_fd_sc_hd__buf_4
XFILLER_51_668 VGND VGND VPWR VPWR sky130_fd_sc_hd__decap_3
XFILLER_51_679 VGND VGND VPWR VPWR sky130_fd_sc_hd__decap_3
X_6743_ _6959_/CLK _6743_/D VGND VGND VPWR VPWR _6743_/Q sky130_fd_sc_hd__dfxtp_2
XFILLER_50_167 VGND VGND VPWR VPWR sky130_fd_sc_hd__fill_2
X_6674_ _6686_/A VGND VGND VPWR VPWR _6674_/Y sky130_fd_sc_hd__inv_2
XTAP_TAPCELL_ROW_21_505 VGND VPWR sky130_fd_sc_hd__tapvpwrvgnd_1
X_3886_ _6920_/Q _3886_/A2 _3886_/B1 _6784_/Q VGND VGND VPWR VPWR _3886_/X sky130_fd_sc_hd__a22o_2
XTAP_TAPCELL_ROW_98_1426 VGND VPWR sky130_fd_sc_hd__tapvpwrvgnd_1
XFILLER_105_615 VGND VGND VPWR VPWR sky130_fd_sc_hd__fill_1
XFILLER_105_626 VGND VGND VPWR VPWR sky130_fd_sc_hd__decap_3
X_4507_ _7326_/Q _7294_/Q _4517_/S VGND VGND VPWR VPWR _7326_/D sky130_fd_sc_hd__mux2_2
XFILLER_105_659 VGND VGND VPWR VPWR sky130_fd_sc_hd__decap_3
XFILLER_116_24 VGND VGND VPWR VPWR sky130_fd_sc_hd__decap_3
X_7226_ _7322_/CLK _7226_/D _6506_/Y VGND VGND VPWR VPWR _7226_/Q sky130_fd_sc_hd__dfrtp_2
X_4438_ _4434_/X _4437_/X _4425_/A VGND VGND VPWR VPWR _4650_/B sky130_fd_sc_hd__o21a_2
XFILLER_104_158 VGND VGND VPWR VPWR sky130_fd_sc_hd__fill_2
XFILLER_116_46 VGND VGND VPWR VPWR sky130_fd_sc_hd__fill_2
XFILLER_116_57 VGND VGND VPWR VPWR sky130_fd_sc_hd__decap_3
X_7157_ _7349_/CLK _7157_/D _6437_/Y VGND VGND VPWR VPWR _7157_/Q sky130_fd_sc_hd__dfrtp_2
X_4369_ _4369_/A _4369_/B VGND VGND VPWR VPWR _4369_/Y sky130_fd_sc_hd__nor2_2
XFILLER_98_392 VGND VGND VPWR VPWR sky130_fd_sc_hd__decap_3
XFILLER_100_342 VGND VGND VPWR VPWR sky130_fd_sc_hd__fill_2
XFILLER_58_267 VGND VGND VPWR VPWR sky130_fd_sc_hd__decap_3
XFILLER_86_554 VGND VGND VPWR VPWR sky130_fd_sc_hd__decap_3
X_7088_ _7351_/CLK _7088_/D _6368_/Y VGND VGND VPWR VPWR _7088_/Q sky130_fd_sc_hd__dfrtp_2
XFILLER_100_375 VGND VGND VPWR VPWR sky130_fd_sc_hd__decap_3
XFILLER_86_587 VGND VGND VPWR VPWR sky130_fd_sc_hd__fill_1
XFILLER_86_598 VGND VGND VPWR VPWR sky130_fd_sc_hd__decap_3
XTAP_TAPCELL_ROW_57_936 VGND VPWR sky130_fd_sc_hd__tapvpwrvgnd_1
XTAP_TAPCELL_ROW_29_605 VGND VPWR sky130_fd_sc_hd__tapvpwrvgnd_1
XFILLER_27_632 VGND VGND VPWR VPWR sky130_fd_sc_hd__decap_3
XTAP_TAPCELL_ROW_107_1533 VGND VPWR sky130_fd_sc_hd__tapvpwrvgnd_1
XFILLER_14_304 VGND VGND VPWR VPWR sky130_fd_sc_hd__decap_3
XFILLER_27_665 VGND VGND VPWR VPWR sky130_fd_sc_hd__decap_3
XFILLER_27_676 VGND VGND VPWR VPWR sky130_fd_sc_hd__decap_3
XFILLER_42_613 VGND VGND VPWR VPWR sky130_fd_sc_hd__decap_3
XTAP_TAPCELL_ROW_1_263 VGND VPWR sky130_fd_sc_hd__tapvpwrvgnd_1
XFILLER_26_197 VGND VGND VPWR VPWR sky130_fd_sc_hd__decap_3
XFILLER_81_281 VGND VGND VPWR VPWR sky130_fd_sc_hd__fill_1
XTAP_TAPCELL_ROW_37_693 VGND VPWR sky130_fd_sc_hd__tapvpwrvgnd_1
XFILLER_14_359 VGND VGND VPWR VPWR sky130_fd_sc_hd__decap_3
XFILLER_41_145 VGND VGND VPWR VPWR sky130_fd_sc_hd__decap_3
XFILLER_42_657 VGND VGND VPWR VPWR sky130_fd_sc_hd__decap_3
XFILLER_41_189 VGND VGND VPWR VPWR sky130_fd_sc_hd__decap_3
XFILLER_22_381 VGND VGND VPWR VPWR sky130_fd_sc_hd__decap_3
XFILLER_50_690 VGND VGND VPWR VPWR sky130_fd_sc_hd__fill_1
XFILLER_10_554 VGND VGND VPWR VPWR sky130_fd_sc_hd__decap_3
XFILLER_10_587 VGND VGND VPWR VPWR sky130_fd_sc_hd__fill_1
XFILLER_41_75 VGND VGND VPWR VPWR sky130_fd_sc_hd__fill_2
XFILLER_6_525 VGND VGND VPWR VPWR sky130_fd_sc_hd__decap_3
XFILLER_6_536 VGND VGND VPWR VPWR sky130_fd_sc_hd__decap_3
XFILLER_108_442 VGND VGND VPWR VPWR sky130_fd_sc_hd__decap_3
XFILLER_10_598 VGND VGND VPWR VPWR sky130_fd_sc_hd__decap_3
XFILLER_6_569 VGND VGND VPWR VPWR sky130_fd_sc_hd__decap_3
XFILLER_108_475 VGND VGND VPWR VPWR sky130_fd_sc_hd__fill_1
XFILLER_108_486 VGND VGND VPWR VPWR sky130_fd_sc_hd__decap_3
XTAP_TAPCELL_ROW_71_1109 VGND VPWR sky130_fd_sc_hd__tapvpwrvgnd_1
XFILLER_111_629 VGND VGND VPWR VPWR sky130_fd_sc_hd__decap_3
XTAP_TAPCELL_ROW_9_363 VGND VPWR sky130_fd_sc_hd__tapvpwrvgnd_1
XFILLER_104_681 VGND VGND VPWR VPWR sky130_fd_sc_hd__decap_3
XFILLER_1_263 VGND VGND VPWR VPWR sky130_fd_sc_hd__decap_3
XFILLER_49_201 VGND VGND VPWR VPWR sky130_fd_sc_hd__fill_1
XFILLER_1_296 VGND VGND VPWR VPWR sky130_fd_sc_hd__decap_3
XFILLER_49_234 VGND VGND VPWR VPWR sky130_fd_sc_hd__decap_3
XFILLER_77_543 VGND VGND VPWR VPWR sky130_fd_sc_hd__decap_3
XFILLER_18_610 VGND VGND VPWR VPWR sky130_fd_sc_hd__decap_3
XFILLER_37_407 VGND VGND VPWR VPWR sky130_fd_sc_hd__decap_3
XFILLER_77_576 VGND VGND VPWR VPWR sky130_fd_sc_hd__decap_3
XFILLER_18_643 VGND VGND VPWR VPWR sky130_fd_sc_hd__fill_1
XFILLER_18_654 VGND VGND VPWR VPWR sky130_fd_sc_hd__decap_3
XFILLER_64_237 VGND VGND VPWR VPWR sky130_fd_sc_hd__decap_3
XFILLER_64_259 VGND VGND VPWR VPWR sky130_fd_sc_hd__decap_3
XFILLER_92_557 VGND VGND VPWR VPWR sky130_fd_sc_hd__decap_3
XFILLER_17_153 VGND VGND VPWR VPWR sky130_fd_sc_hd__fill_1
XFILLER_18_687 VGND VGND VPWR VPWR sky130_fd_sc_hd__decap_3
XFILLER_33_635 VGND VGND VPWR VPWR sky130_fd_sc_hd__decap_3
XFILLER_60_421 VGND VGND VPWR VPWR sky130_fd_sc_hd__decap_3
XTAP_TAPCELL_ROW_82_1238 VGND VPWR sky130_fd_sc_hd__tapvpwrvgnd_1
XFILLER_33_668 VGND VGND VPWR VPWR sky130_fd_sc_hd__decap_3
XFILLER_33_679 VGND VGND VPWR VPWR sky130_fd_sc_hd__decap_3
XFILLER_60_443 VGND VGND VPWR VPWR sky130_fd_sc_hd__fill_2
XFILLER_82_71 VGND VGND VPWR VPWR sky130_fd_sc_hd__decap_3
XFILLER_32_178 VGND VGND VPWR VPWR sky130_fd_sc_hd__decap_3
X_3740_ _6710_/Q _3913_/B1 _3888_/B1 _6888_/Q _3739_/X VGND VGND VPWR VPWR _3740_/X
+ sky130_fd_sc_hd__a221o_2
X_3671_ _3671_/A1 _4832_/A _3670_/X VGND VGND VPWR VPWR _7405_/D sky130_fd_sc_hd__o21a_2
XFILLER_63_3 VGND VGND VPWR VPWR sky130_fd_sc_hd__decap_3
X_6390_ _6581_/A VGND VGND VPWR VPWR _6390_/Y sky130_fd_sc_hd__inv_2
XFILLER_114_401 VGND VGND VPWR VPWR sky130_fd_sc_hd__decap_3
XFILLER_99_101 VGND VGND VPWR VPWR sky130_fd_sc_hd__decap_3
XFILLER_114_445 VGND VGND VPWR VPWR sky130_fd_sc_hd__decap_3
XFILLER_5_591 VGND VGND VPWR VPWR sky130_fd_sc_hd__decap_3
XTAP_TAPCELL_ROW_93_1367 VGND VPWR sky130_fd_sc_hd__tapvpwrvgnd_1
XFILLER_102_607 VGND VGND VPWR VPWR sky130_fd_sc_hd__decap_3
X_7011_ _7353_/CLK _7011_/D _6291_/Y VGND VGND VPWR VPWR _7011_/Q sky130_fd_sc_hd__dfrtp_2
X_5272_ _5272_/A0 _5061_/X _5286_/S VGND VGND VPWR VPWR _7194_/D sky130_fd_sc_hd__mux2_2
XFILLER_99_167 VGND VGND VPWR VPWR sky130_fd_sc_hd__fill_1
XFILLER_101_128 VGND VGND VPWR VPWR sky130_fd_sc_hd__decap_3
XFILLER_114_489 VGND VGND VPWR VPWR sky130_fd_sc_hd__decap_3
X_4223_ _4217_/X _4219_/X _4222_/X _3424_/S VGND VGND VPWR VPWR _4224_/C sky130_fd_sc_hd__o31a_2
XFILLER_110_640 VGND VGND VPWR VPWR sky130_fd_sc_hd__decap_3
XFILLER_110_651 VGND VGND VPWR VPWR sky130_fd_sc_hd__decap_3
XFILLER_68_565 VGND VGND VPWR VPWR sky130_fd_sc_hd__decap_3
XFILLER_95_351 VGND VGND VPWR VPWR sky130_fd_sc_hd__fill_2
X_4154_ _7047_/Q _4478_/S _4419_/B1 _7394_/Q _4153_/X VGND VGND VPWR VPWR _4154_/X
+ sky130_fd_sc_hd__a221o_2
XFILLER_110_684 VGND VGND VPWR VPWR sky130_fd_sc_hd__decap_3
XFILLER_68_598 VGND VGND VPWR VPWR sky130_fd_sc_hd__decap_3
XFILLER_95_362 VGND VGND VPWR VPWR sky130_fd_sc_hd__decap_3
X_4085_ _7238_/Q _4430_/A2 _4420_/B1 _7142_/Q _4084_/X VGND VGND VPWR VPWR _4085_/X
+ sky130_fd_sc_hd__a221o_2
XFILLER_83_535 VGND VGND VPWR VPWR sky130_fd_sc_hd__decap_3
XFILLER_36_462 VGND VGND VPWR VPWR sky130_fd_sc_hd__decap_3
XFILLER_83_579 VGND VGND VPWR VPWR sky130_fd_sc_hd__decap_3
XFILLER_24_613 VGND VGND VPWR VPWR sky130_fd_sc_hd__decap_3
XFILLER_51_421 VGND VGND VPWR VPWR sky130_fd_sc_hd__decap_3
XFILLER_63_270 VGND VGND VPWR VPWR sky130_fd_sc_hd__decap_3
XFILLER_63_281 VGND VGND VPWR VPWR sky130_fd_sc_hd__decap_3
XFILLER_70_229 VGND VGND VPWR VPWR sky130_fd_sc_hd__decap_3
XFILLER_24_657 VGND VGND VPWR VPWR sky130_fd_sc_hd__decap_3
XFILLER_51_443 VGND VGND VPWR VPWR sky130_fd_sc_hd__decap_3
Xplace281 _3888_/A2 VGND VGND VPWR VPWR _3926_/A2 sky130_fd_sc_hd__buf_2
Xplace270 _5660_/A VGND VGND VPWR VPWR _3629_/A sky130_fd_sc_hd__buf_2
XFILLER_23_189 VGND VGND VPWR VPWR sky130_fd_sc_hd__decap_3
Xplace292 _3903_/B1 VGND VGND VPWR VPWR _3925_/A2 sky130_fd_sc_hd__buf_2
X_6726_ clkload6/A _6726_/D VGND VGND VPWR VPWR _6726_/Q sky130_fd_sc_hd__dfxtp_2
X_4987_ _4987_/A _4987_/B VGND VGND VPWR VPWR _4987_/Y sky130_fd_sc_hd__xnor2_2
XTAP_TAPCELL_ROW_62_994 VGND VPWR sky130_fd_sc_hd__tapvpwrvgnd_1
XTAP_TAPCELL_ROW_34_663 VGND VPWR sky130_fd_sc_hd__tapvpwrvgnd_1
XFILLER_32_690 VGND VGND VPWR VPWR sky130_fd_sc_hd__fill_1
XTAP_TAPCELL_ROW_102_1474 VGND VPWR sky130_fd_sc_hd__tapvpwrvgnd_1
XFILLER_109_228 VGND VGND VPWR VPWR sky130_fd_sc_hd__decap_3
X_6657_ _6663_/A VGND VGND VPWR VPWR _6657_/Y sky130_fd_sc_hd__inv_2
X_3869_ _6772_/Q _3926_/A2 _3883_/B1 _6766_/Q VGND VGND VPWR VPWR _3869_/X sky130_fd_sc_hd__a22o_2
X_6588_ _6622_/A VGND VGND VPWR VPWR _6588_/Y sky130_fd_sc_hd__inv_2
XFILLER_3_517 VGND VGND VPWR VPWR sky130_fd_sc_hd__decap_3
XFILLER_105_456 VGND VGND VPWR VPWR sky130_fd_sc_hd__decap_3
XFILLER_78_318 VGND VGND VPWR VPWR sky130_fd_sc_hd__decap_3
XPHY_EDGE_ROW_52_Left_169 VGND VGND VPWR VPWR sky130_fd_sc_hd__decap_3
XFILLER_105_489 VGND VGND VPWR VPWR sky130_fd_sc_hd__decap_3
X_7209_ _7405_/CLK _7209_/D _6489_/Y VGND VGND VPWR VPWR _7209_/Q sky130_fd_sc_hd__dfrtp_2
XTAP_TAPCELL_ROW_6_322 VGND VPWR sky130_fd_sc_hd__tapvpwrvgnd_1
XFILLER_101_662 VGND VGND VPWR VPWR sky130_fd_sc_hd__decap_3
XFILLER_101_673 VGND VGND VPWR VPWR sky130_fd_sc_hd__decap_3
XFILLER_59_576 VGND VGND VPWR VPWR sky130_fd_sc_hd__decap_3
XFILLER_86_362 VGND VGND VPWR VPWR sky130_fd_sc_hd__fill_2
XFILLER_100_172 VGND VGND VPWR VPWR sky130_fd_sc_hd__decap_3
XFILLER_46_237 VGND VGND VPWR VPWR sky130_fd_sc_hd__decap_3
XFILLER_74_557 VGND VGND VPWR VPWR sky130_fd_sc_hd__decap_3
XFILLER_15_635 VGND VGND VPWR VPWR sky130_fd_sc_hd__decap_3
XFILLER_42_421 VGND VGND VPWR VPWR sky130_fd_sc_hd__fill_1
XFILLER_54_281 VGND VGND VPWR VPWR sky130_fd_sc_hd__fill_1
XTAP_TAPCELL_ROW_68_1071 VGND VPWR sky130_fd_sc_hd__tapvpwrvgnd_1
XPHY_EDGE_ROW_61_Left_178 VGND VGND VPWR VPWR sky130_fd_sc_hd__decap_3
XFILLER_15_668 VGND VGND VPWR VPWR sky130_fd_sc_hd__decap_3
XFILLER_15_679 VGND VGND VPWR VPWR sky130_fd_sc_hd__decap_3
XFILLER_14_156 VGND VGND VPWR VPWR sky130_fd_sc_hd__decap_3
XFILLER_30_616 VGND VGND VPWR VPWR sky130_fd_sc_hd__decap_3
XFILLER_42_498 VGND VGND VPWR VPWR sky130_fd_sc_hd__decap_3
XFILLER_52_85 VGND VGND VPWR VPWR sky130_fd_sc_hd__fill_2
XFILLER_10_340 VGND VGND VPWR VPWR sky130_fd_sc_hd__fill_2
XFILLER_6_300 VGND VGND VPWR VPWR sky130_fd_sc_hd__decap_3
XPHY_EDGE_ROW_70_Left_187 VGND VGND VPWR VPWR sky130_fd_sc_hd__decap_3
XFILLER_111_426 VGND VGND VPWR VPWR sky130_fd_sc_hd__decap_3
XFILLER_2_572 VGND VGND VPWR VPWR sky130_fd_sc_hd__decap_3
XFILLER_69_318 VGND VGND VPWR VPWR sky130_fd_sc_hd__decap_3
XFILLER_96_126 VGND VGND VPWR VPWR sky130_fd_sc_hd__decap_3
XFILLER_97_638 VGND VGND VPWR VPWR sky130_fd_sc_hd__decap_3
XFILLER_77_71 VGND VGND VPWR VPWR sky130_fd_sc_hd__fill_2
XFILLER_96_159 VGND VGND VPWR VPWR sky130_fd_sc_hd__decap_3
XFILLER_77_362 VGND VGND VPWR VPWR sky130_fd_sc_hd__decap_3
XFILLER_37_259 VGND VGND VPWR VPWR sky130_fd_sc_hd__decap_3
XFILLER_65_579 VGND VGND VPWR VPWR sky130_fd_sc_hd__decap_3
X_4910_ _5092_/C _4910_/B VGND VGND VPWR VPWR _4910_/Y sky130_fd_sc_hd__nand2_2
XFILLER_33_432 VGND VGND VPWR VPWR sky130_fd_sc_hd__fill_1
XFILLER_45_292 VGND VGND VPWR VPWR sky130_fd_sc_hd__decap_3
X_4841_ _4890_/B _4888_/B VGND VGND VPWR VPWR _4841_/Y sky130_fd_sc_hd__nand2b_2
XFILLER_21_638 VGND VGND VPWR VPWR sky130_fd_sc_hd__decap_3
XFILLER_33_465 VGND VGND VPWR VPWR sky130_fd_sc_hd__decap_3
XFILLER_60_262 VGND VGND VPWR VPWR sky130_fd_sc_hd__decap_3
XFILLER_60_273 VGND VGND VPWR VPWR sky130_fd_sc_hd__decap_3
XFILLER_14_690 VGND VGND VPWR VPWR sky130_fd_sc_hd__fill_1
X_4772_ _4772_/A0 _4771_/X _4837_/S VGND VGND VPWR VPWR _7275_/D sky130_fd_sc_hd__mux2_2
XTAP_TAPCELL_ROW_31_622 VGND VPWR sky130_fd_sc_hd__tapvpwrvgnd_1
X_6511_ _6581_/A VGND VGND VPWR VPWR _6511_/Y sky130_fd_sc_hd__inv_2
X_3723_ _6813_/Q _3878_/A2 _3892_/B1 _6823_/Q VGND VGND VPWR VPWR _3723_/X sky130_fd_sc_hd__a22o_2
X_6442_ _6640_/A VGND VGND VPWR VPWR _6442_/Y sky130_fd_sc_hd__inv_2
X_6373_ _6566_/A VGND VGND VPWR VPWR _6373_/Y sky130_fd_sc_hd__inv_2
X_3585_ _3591_/A _3591_/B _3591_/C _3586_/D VGND VGND VPWR VPWR _3599_/A sky130_fd_sc_hd__o31a_2
XFILLER_88_616 VGND VGND VPWR VPWR sky130_fd_sc_hd__decap_3
XFILLER_68_340 VGND VGND VPWR VPWR sky130_fd_sc_hd__decap_3
XFILLER_87_148 VGND VGND VPWR VPWR sky130_fd_sc_hd__decap_3
X_4206_ _4920_/A _4204_/Y _4205_/X VGND VGND VPWR VPWR _4206_/X sky130_fd_sc_hd__a21o_2
XFILLER_68_351 VGND VGND VPWR VPWR sky130_fd_sc_hd__decap_3
XFILLER_96_660 VGND VGND VPWR VPWR sky130_fd_sc_hd__decap_3
X_5186_ _5186_/A _5190_/B VGND VGND VPWR VPWR _7235_/D sky130_fd_sc_hd__and2_2
XFILLER_110_492 VGND VGND VPWR VPWR sky130_fd_sc_hd__decap_3
XFILLER_113_14 VGND VGND VPWR VPWR sky130_fd_sc_hd__decap_3
XFILLER_28_248 VGND VGND VPWR VPWR sky130_fd_sc_hd__decap_3
XFILLER_68_395 VGND VGND VPWR VPWR sky130_fd_sc_hd__fill_1
X_4137_ _7048_/Q _4478_/S _4419_/B1 _7395_/Q _4136_/X VGND VGND VPWR VPWR _4137_/X
+ sky130_fd_sc_hd__a221o_2
XTAP_TAPCELL_ROW_39_722 VGND VPWR sky130_fd_sc_hd__tapvpwrvgnd_1
XFILLER_113_47 VGND VGND VPWR VPWR sky130_fd_sc_hd__decap_3
XFILLER_113_69 VGND VGND VPWR VPWR sky130_fd_sc_hd__decap_3
XFILLER_28_259 VGND VGND VPWR VPWR sky130_fd_sc_hd__decap_3
XFILLER_56_579 VGND VGND VPWR VPWR sky130_fd_sc_hd__decap_3
XFILLER_83_343 VGND VGND VPWR VPWR sky130_fd_sc_hd__decap_3
X_4068_ _4068_/A _4082_/A VGND VGND VPWR VPWR _4069_/B sky130_fd_sc_hd__nor2_2
XFILLER_43_218 VGND VGND VPWR VPWR sky130_fd_sc_hd__decap_3
XFILLER_71_549 VGND VGND VPWR VPWR sky130_fd_sc_hd__decap_3
XFILLER_73_29 VGND VGND VPWR VPWR sky130_fd_sc_hd__decap_3
XFILLER_83_387 VGND VGND VPWR VPWR sky130_fd_sc_hd__decap_3
XTAP_TAPCELL_ROW_104_1503 VGND VPWR sky130_fd_sc_hd__tapvpwrvgnd_1
XFILLER_24_443 VGND VGND VPWR VPWR sky130_fd_sc_hd__decap_3
XFILLER_12_616 VGND VGND VPWR VPWR sky130_fd_sc_hd__decap_3
XFILLER_51_251 VGND VGND VPWR VPWR sky130_fd_sc_hd__decap_3
XFILLER_51_295 VGND VGND VPWR VPWR sky130_fd_sc_hd__decap_3
XFILLER_20_660 VGND VGND VPWR VPWR sky130_fd_sc_hd__decap_3
X_6709_ _6941_/CLK _6709_/D VGND VGND VPWR VPWR _6709_/Q sky130_fd_sc_hd__dfxtp_2
XFILLER_98_15 VGND VGND VPWR VPWR sky130_fd_sc_hd__decap_3
XFILLER_3_303 VGND VGND VPWR VPWR sky130_fd_sc_hd__decap_3
XTAP_TAPCELL_ROW_115_1632 VGND VPWR sky130_fd_sc_hd__tapvpwrvgnd_1
XFILLER_98_37 VGND VGND VPWR VPWR sky130_fd_sc_hd__fill_1
XFILLER_105_231 VGND VGND VPWR VPWR sky130_fd_sc_hd__fill_1
XFILLER_105_275 VGND VGND VPWR VPWR sky130_fd_sc_hd__decap_3
XFILLER_79_638 VGND VGND VPWR VPWR sky130_fd_sc_hd__decap_3
XFILLER_59_340 VGND VGND VPWR VPWR sky130_fd_sc_hd__decap_3
XFILLER_78_159 VGND VGND VPWR VPWR sky130_fd_sc_hd__decap_3
Xoutput490 _5658_/C VGND VGND VPWR VPWR alu_result_out[9] sky130_fd_sc_hd__clkdlybuf4s25_1
XFILLER_47_513 VGND VGND VPWR VPWR sky130_fd_sc_hd__fill_1
XFILLER_59_373 VGND VGND VPWR VPWR sky130_fd_sc_hd__fill_1
XFILLER_87_671 VGND VGND VPWR VPWR sky130_fd_sc_hd__fill_1
XFILLER_87_682 VGND VGND VPWR VPWR sky130_fd_sc_hd__decap_3
XFILLER_94_619 VGND VGND VPWR VPWR sky130_fd_sc_hd__decap_3
XFILLER_101_492 VGND VGND VPWR VPWR sky130_fd_sc_hd__decap_3
XFILLER_74_321 VGND VGND VPWR VPWR sky130_fd_sc_hd__decap_3
XFILLER_47_579 VGND VGND VPWR VPWR sky130_fd_sc_hd__decap_3
XFILLER_47_74 VGND VGND VPWR VPWR sky130_fd_sc_hd__decap_3
XFILLER_74_365 VGND VGND VPWR VPWR sky130_fd_sc_hd__decap_3
XFILLER_34_229 VGND VGND VPWR VPWR sky130_fd_sc_hd__decap_3
XFILLER_74_398 VGND VGND VPWR VPWR sky130_fd_sc_hd__fill_1
XFILLER_103_91 VGND VGND VPWR VPWR sky130_fd_sc_hd__fill_2
XFILLER_27_281 VGND VGND VPWR VPWR sky130_fd_sc_hd__decap_3
XFILLER_63_51 VGND VGND VPWR VPWR sky130_fd_sc_hd__decap_3
XFILLER_42_251 VGND VGND VPWR VPWR sky130_fd_sc_hd__fill_1
XFILLER_42_273 VGND VGND VPWR VPWR sky130_fd_sc_hd__decap_3
XFILLER_63_84 VGND VGND VPWR VPWR sky130_fd_sc_hd__decap_3
XFILLER_70_582 VGND VGND VPWR VPWR sky130_fd_sc_hd__decap_3
XFILLER_97_9 VGND VGND VPWR VPWR sky130_fd_sc_hd__decap_3
XFILLER_8_46 VGND VGND VPWR VPWR sky130_fd_sc_hd__decap_3
XFILLER_11_671 VGND VGND VPWR VPWR sky130_fd_sc_hd__fill_1
XFILLER_11_682 VGND VGND VPWR VPWR sky130_fd_sc_hd__decap_3
XFILLER_7_620 VGND VGND VPWR VPWR sky130_fd_sc_hd__decap_3
XFILLER_6_130 VGND VGND VPWR VPWR sky130_fd_sc_hd__fill_2
XFILLER_6_141 VGND VGND VPWR VPWR sky130_fd_sc_hd__fill_1
XFILLER_7_653 VGND VGND VPWR VPWR sky130_fd_sc_hd__decap_3
Xhold609 _6967_/Q VGND VGND VPWR VPWR _6967_/D sky130_fd_sc_hd__dlygate4sd3_1
XFILLER_109_570 VGND VGND VPWR VPWR sky130_fd_sc_hd__decap_3
XFILLER_6_163 VGND VGND VPWR VPWR sky130_fd_sc_hd__decap_3
X_3370_ _3561_/A _6983_/Q VGND VGND VPWR VPWR _3370_/Y sky130_fd_sc_hd__nor2_2
XFILLER_97_402 VGND VGND VPWR VPWR sky130_fd_sc_hd__decap_3
XFILLER_97_424 VGND VGND VPWR VPWR sky130_fd_sc_hd__decap_3
XTAP_TAPCELL_ROW_90_1337 VGND VPWR sky130_fd_sc_hd__tapvpwrvgnd_1
XTAP_TAPCELL_ROW_90_1326 VGND VPWR sky130_fd_sc_hd__tapvpwrvgnd_1
XFILLER_69_137 VGND VGND VPWR VPWR sky130_fd_sc_hd__fill_1
XFILLER_69_148 VGND VGND VPWR VPWR sky130_fd_sc_hd__decap_3
XFILLER_97_457 VGND VGND VPWR VPWR sky130_fd_sc_hd__decap_3
X_5040_ _6989_/D _5039_/X _5040_/S VGND VGND VPWR VPWR _5040_/X sky130_fd_sc_hd__mux2_2
XFILLER_111_278 VGND VGND VPWR VPWR sky130_fd_sc_hd__fill_2
XFILLER_26_3 VGND VGND VPWR VPWR sky130_fd_sc_hd__decap_3
XFILLER_78_660 VGND VGND VPWR VPWR sky130_fd_sc_hd__decap_3
XFILLER_97_479 VGND VGND VPWR VPWR sky130_fd_sc_hd__decap_3
XPHY_EDGE_ROW_108_Left_225 VGND VGND VPWR VPWR sky130_fd_sc_hd__decap_3
XFILLER_77_192 VGND VGND VPWR VPWR sky130_fd_sc_hd__decap_3
XFILLER_84_129 VGND VGND VPWR VPWR sky130_fd_sc_hd__decap_3
XFILLER_93_641 VGND VGND VPWR VPWR sky130_fd_sc_hd__decap_3
XFILLER_38_557 VGND VGND VPWR VPWR sky130_fd_sc_hd__decap_3
XFILLER_65_343 VGND VGND VPWR VPWR sky130_fd_sc_hd__decap_3
X_6991_ _7144_/CLK _6991_/D _6271_/Y VGND VGND VPWR VPWR _6991_/Q sky130_fd_sc_hd__dfrtp_2
XFILLER_25_218 VGND VGND VPWR VPWR sky130_fd_sc_hd__decap_3
XFILLER_93_685 VGND VGND VPWR VPWR sky130_fd_sc_hd__decap_3
XFILLER_18_292 VGND VGND VPWR VPWR sky130_fd_sc_hd__fill_2
XFILLER_80_368 VGND VGND VPWR VPWR sky130_fd_sc_hd__decap_3
XFILLER_33_240 VGND VGND VPWR VPWR sky130_fd_sc_hd__decap_3
XFILLER_33_273 VGND VGND VPWR VPWR sky130_fd_sc_hd__decap_3
XFILLER_33_284 VGND VGND VPWR VPWR sky130_fd_sc_hd__decap_3
XFILLER_61_582 VGND VGND VPWR VPWR sky130_fd_sc_hd__decap_3
XTAP_TAPCELL_ROW_44_780 VGND VPWR sky130_fd_sc_hd__tapvpwrvgnd_1
XFILLER_21_468 VGND VGND VPWR VPWR sky130_fd_sc_hd__fill_2
X_4755_ _7005_/Q _4775_/A VGND VGND VPWR VPWR _7005_/D sky130_fd_sc_hd__xor2_2
XFILLER_107_529 VGND VGND VPWR VPWR sky130_fd_sc_hd__decap_3
X_4686_ _6999_/Q _7000_/Q _4858_/B VGND VGND VPWR VPWR _4687_/B sky130_fd_sc_hd__and3_2
X_6425_ _6649_/A VGND VGND VPWR VPWR _6425_/Y sky130_fd_sc_hd__inv_2
X_3637_ _3636_/Y _5146_/B1 _3505_/X _3618_/X VGND VGND VPWR VPWR _3637_/X sky130_fd_sc_hd__a22o_2
XFILLER_108_47 VGND VGND VPWR VPWR sky130_fd_sc_hd__decap_3
X_6356_ _6685_/A VGND VGND VPWR VPWR _6356_/Y sky130_fd_sc_hd__inv_2
X_3568_ _7093_/Q _3417_/X _3407_/X _7125_/Q VGND VGND VPWR VPWR _3568_/X sky130_fd_sc_hd__a22o_2
XFILLER_115_573 VGND VGND VPWR VPWR sky130_fd_sc_hd__decap_3
XFILLER_68_18 VGND VGND VPWR VPWR sky130_fd_sc_hd__decap_3
XFILLER_68_29 VGND VGND VPWR VPWR sky130_fd_sc_hd__fill_1
XFILLER_88_424 VGND VGND VPWR VPWR sky130_fd_sc_hd__decap_3
X_6287_ _6288_/A VGND VGND VPWR VPWR _6287_/Y sky130_fd_sc_hd__inv_2
X_3499_ _4537_/C _5699_/S _3497_/X _5152_/B VGND VGND VPWR VPWR _3541_/B sky130_fd_sc_hd__a31oi_4
XFILLER_102_278 VGND VGND VPWR VPWR sky130_fd_sc_hd__decap_3
XFILLER_29_502 VGND VGND VPWR VPWR sky130_fd_sc_hd__fill_2
XFILLER_29_513 VGND VGND VPWR VPWR sky130_fd_sc_hd__fill_2
XFILLER_69_671 VGND VGND VPWR VPWR sky130_fd_sc_hd__fill_1
XFILLER_76_619 VGND VGND VPWR VPWR sky130_fd_sc_hd__decap_3
X_5238_ _5362_/C _5238_/B _5229_/C VGND VGND VPWR VPWR _5238_/X sky130_fd_sc_hd__or3b_2
XTAP_TAPCELL_ROW_110_1573 VGND VPWR sky130_fd_sc_hd__tapvpwrvgnd_1
XFILLER_56_321 VGND VGND VPWR VPWR sky130_fd_sc_hd__decap_3
XFILLER_56_332 VGND VGND VPWR VPWR sky130_fd_sc_hd__decap_3
XFILLER_69_682 VGND VGND VPWR VPWR sky130_fd_sc_hd__decap_3
X_5169_ _5169_/A _5177_/B VGND VGND VPWR VPWR _7243_/D sky130_fd_sc_hd__and2_2
XFILLER_29_557 VGND VGND VPWR VPWR sky130_fd_sc_hd__decap_3
XFILLER_29_579 VGND VGND VPWR VPWR sky130_fd_sc_hd__decap_3
XFILLER_56_365 VGND VGND VPWR VPWR sky130_fd_sc_hd__decap_3
XFILLER_68_192 VGND VGND VPWR VPWR sky130_fd_sc_hd__decap_3
XFILLER_84_663 VGND VGND VPWR VPWR sky130_fd_sc_hd__decap_3
XFILLER_56_398 VGND VGND VPWR VPWR sky130_fd_sc_hd__decap_3
XFILLER_71_313 VGND VGND VPWR VPWR sky130_fd_sc_hd__decap_3
XFILLER_17_77 VGND VGND VPWR VPWR sky130_fd_sc_hd__fill_2
XTAP_TAPCELL_ROW_65_1030 VGND VPWR sky130_fd_sc_hd__tapvpwrvgnd_1
XFILLER_24_262 VGND VGND VPWR VPWR sky130_fd_sc_hd__decap_3
XFILLER_52_571 VGND VGND VPWR VPWR sky130_fd_sc_hd__decap_3
XFILLER_71_379 VGND VGND VPWR VPWR sky130_fd_sc_hd__fill_1
XTAP_TAPCELL_ROW_14_419 VGND VPWR sky130_fd_sc_hd__tapvpwrvgnd_1
XFILLER_24_295 VGND VGND VPWR VPWR sky130_fd_sc_hd__decap_3
XFILLER_33_54 VGND VGND VPWR VPWR sky130_fd_sc_hd__fill_2
XFILLER_33_65 VGND VGND VPWR VPWR sky130_fd_sc_hd__decap_3
XFILLER_8_439 VGND VGND VPWR VPWR sky130_fd_sc_hd__decap_3
XFILLER_4_601 VGND VGND VPWR VPWR sky130_fd_sc_hd__decap_3
XFILLER_4_634 VGND VGND VPWR VPWR sky130_fd_sc_hd__decap_3
XFILLER_106_551 VGND VGND VPWR VPWR sky130_fd_sc_hd__decap_3
XFILLER_4_645 VGND VGND VPWR VPWR sky130_fd_sc_hd__decap_3
XFILLER_106_584 VGND VGND VPWR VPWR sky130_fd_sc_hd__decap_3
XFILLER_3_166 VGND VGND VPWR VPWR sky130_fd_sc_hd__fill_2
XFILLER_4_678 VGND VGND VPWR VPWR sky130_fd_sc_hd__decap_3
XFILLER_79_402 VGND VGND VPWR VPWR sky130_fd_sc_hd__decap_3
XFILLER_106_595 VGND VGND VPWR VPWR sky130_fd_sc_hd__decap_3
XFILLER_79_446 VGND VGND VPWR VPWR sky130_fd_sc_hd__fill_2
XFILLER_79_457 VGND VGND VPWR VPWR sky130_fd_sc_hd__decap_3
XFILLER_58_62 VGND VGND VPWR VPWR sky130_fd_sc_hd__decap_3
XFILLER_94_405 VGND VGND VPWR VPWR sky130_fd_sc_hd__decap_3
XFILLER_59_181 VGND VGND VPWR VPWR sky130_fd_sc_hd__decap_3
XFILLER_35_505 VGND VGND VPWR VPWR sky130_fd_sc_hd__decap_3
XFILLER_47_343 VGND VGND VPWR VPWR sky130_fd_sc_hd__decap_3
XFILLER_75_641 VGND VGND VPWR VPWR sky130_fd_sc_hd__decap_3
XFILLER_62_302 VGND VGND VPWR VPWR sky130_fd_sc_hd__decap_3
XFILLER_74_151 VGND VGND VPWR VPWR sky130_fd_sc_hd__decap_3
XFILLER_75_685 VGND VGND VPWR VPWR sky130_fd_sc_hd__decap_3
XFILLER_90_622 VGND VGND VPWR VPWR sky130_fd_sc_hd__decap_3
XFILLER_74_195 VGND VGND VPWR VPWR sky130_fd_sc_hd__fill_1
XFILLER_90_666 VGND VGND VPWR VPWR sky130_fd_sc_hd__decap_3
XFILLER_15_240 VGND VGND VPWR VPWR sky130_fd_sc_hd__fill_2
XFILLER_43_582 VGND VGND VPWR VPWR sky130_fd_sc_hd__decap_3
XFILLER_30_232 VGND VGND VPWR VPWR sky130_fd_sc_hd__decap_3
XFILLER_30_265 VGND VGND VPWR VPWR sky130_fd_sc_hd__decap_3
XFILLER_116_304 VGND VGND VPWR VPWR sky130_fd_sc_hd__decap_3
Xclkbuf_leaf_10_clk clkbuf_leaf_9_clk/A VGND VGND VPWR VPWR _6943_/CLK sky130_fd_sc_hd__clkbuf_16
X_4540_ _4540_/A _4563_/B VGND VGND VPWR VPWR _7310_/D sky130_fd_sc_hd__and2_2
XFILLER_116_326 VGND VGND VPWR VPWR sky130_fd_sc_hd__decap_3
X_4471_ _7343_/Q _4470_/X _4471_/S VGND VGND VPWR VPWR _7343_/D sky130_fd_sc_hd__mux2_2
XFILLER_116_348 VGND VGND VPWR VPWR sky130_fd_sc_hd__fill_1
X_7190_ _7350_/CLK _7190_/D _6470_/Y VGND VGND VPWR VPWR _7190_/Q sky130_fd_sc_hd__dfrtp_2
XFILLER_112_510 VGND VGND VPWR VPWR sky130_fd_sc_hd__decap_3
X_3353_ _3365_/A _5129_/B VGND VGND VPWR VPWR _5668_/A sky130_fd_sc_hd__xor2_2
XFILLER_112_554 VGND VGND VPWR VPWR sky130_fd_sc_hd__decap_3
XFILLER_112_587 VGND VGND VPWR VPWR sky130_fd_sc_hd__fill_1
XFILLER_58_619 VGND VGND VPWR VPWR sky130_fd_sc_hd__decap_3
XFILLER_97_276 VGND VGND VPWR VPWR sky130_fd_sc_hd__decap_3
Xhold1106 _6691_/Q VGND VGND VPWR VPWR _5682_/A1 sky130_fd_sc_hd__dlygate4sd3_1
XFILLER_112_598 VGND VGND VPWR VPWR sky130_fd_sc_hd__decap_3
XFILLER_38_321 VGND VGND VPWR VPWR sky130_fd_sc_hd__decap_3
XFILLER_85_438 VGND VGND VPWR VPWR sky130_fd_sc_hd__decap_3
XFILLER_97_287 VGND VGND VPWR VPWR sky130_fd_sc_hd__fill_2
Xhold1117 _4599_/X VGND VGND VPWR VPWR _7281_/D sky130_fd_sc_hd__dlygate4sd3_1
Xhold1128 _7179_/Q VGND VGND VPWR VPWR _5302_/A0 sky130_fd_sc_hd__dlygate4sd3_1
Xhold1139 _7336_/Q VGND VGND VPWR VPWR _4486_/A0 sky130_fd_sc_hd__dlygate4sd3_1
X_5023_ _5661_/A VGND VGND VPWR VPWR _5023_/Y sky130_fd_sc_hd__inv_2
XFILLER_38_354 VGND VGND VPWR VPWR sky130_fd_sc_hd__decap_3
XFILLER_66_663 VGND VGND VPWR VPWR sky130_fd_sc_hd__decap_3
Xsingle_cycle_cpu_580 VGND VGND VPWR VPWR instruction_out[1] single_cycle_cpu_580/LO
+ sky130_fd_sc_hd__conb_1
XFILLER_38_365 VGND VGND VPWR VPWR sky130_fd_sc_hd__decap_3
XFILLER_53_302 VGND VGND VPWR VPWR sky130_fd_sc_hd__decap_3
XFILLER_65_151 VGND VGND VPWR VPWR sky130_fd_sc_hd__decap_3
XFILLER_81_600 VGND VGND VPWR VPWR sky130_fd_sc_hd__decap_3
XFILLER_93_460 VGND VGND VPWR VPWR sky130_fd_sc_hd__fill_1
XFILLER_53_346 VGND VGND VPWR VPWR sky130_fd_sc_hd__decap_3
XFILLER_65_184 VGND VGND VPWR VPWR sky130_fd_sc_hd__decap_3
XFILLER_81_644 VGND VGND VPWR VPWR sky130_fd_sc_hd__decap_3
X_6974_ _6974_/CLK _6974_/D VGND VGND VPWR VPWR _6974_/Q sky130_fd_sc_hd__dfxtp_2
XFILLER_110_15 VGND VGND VPWR VPWR sky130_fd_sc_hd__decap_3
XFILLER_34_571 VGND VGND VPWR VPWR sky130_fd_sc_hd__decap_3
XFILLER_80_165 VGND VGND VPWR VPWR sky130_fd_sc_hd__fill_2
XFILLER_81_688 VGND VGND VPWR VPWR sky130_fd_sc_hd__decap_3
XFILLER_110_59 VGND VGND VPWR VPWR sky130_fd_sc_hd__decap_3
X_4807_ _4807_/A0 _4806_/X _4837_/S VGND VGND VPWR VPWR _7273_/D sky130_fd_sc_hd__mux2_2
XPHY_EDGE_ROW_3_Right_3 VGND VGND VPWR VPWR sky130_fd_sc_hd__decap_3
XFILLER_21_298 VGND VGND VPWR VPWR sky130_fd_sc_hd__fill_1
X_4738_ _4738_/A _4738_/B VGND VGND VPWR VPWR _7006_/D sky130_fd_sc_hd__nor2_2
XFILLER_107_337 VGND VGND VPWR VPWR sky130_fd_sc_hd__decap_3
X_4669_ _6995_/Q _5633_/B VGND VGND VPWR VPWR _4928_/B sky130_fd_sc_hd__and2_2
Xhold940 _7395_/Q VGND VGND VPWR VPWR hold940/X sky130_fd_sc_hd__dlygate4sd3_1
X_6408_ _6633_/A VGND VGND VPWR VPWR _6408_/Y sky130_fd_sc_hd__inv_2
XFILLER_1_604 VGND VGND VPWR VPWR sky130_fd_sc_hd__decap_3
XFILLER_1_626 VGND VGND VPWR VPWR sky130_fd_sc_hd__decap_3
X_7388_ _7398_/CLK _7388_/D _6668_/Y VGND VGND VPWR VPWR _7388_/Q sky130_fd_sc_hd__dfrtp_2
Xhold973 _7044_/Q VGND VGND VPWR VPWR hold973/X sky130_fd_sc_hd__dlygate4sd3_1
Xhold962 _7034_/Q VGND VGND VPWR VPWR _5587_/A sky130_fd_sc_hd__dlygate4sd3_1
Xhold951 _7048_/Q VGND VGND VPWR VPWR hold951/X sky130_fd_sc_hd__dlygate4sd3_1
XFILLER_103_532 VGND VGND VPWR VPWR sky130_fd_sc_hd__decap_3
XFILLER_88_232 VGND VGND VPWR VPWR sky130_fd_sc_hd__decap_3
Xhold995 _7254_/Q VGND VGND VPWR VPWR hold995/X sky130_fd_sc_hd__dlygate4sd3_1
Xhold984 _6699_/Q VGND VGND VPWR VPWR hold984/X sky130_fd_sc_hd__dlygate4sd3_1
X_6339_ _6629_/A VGND VGND VPWR VPWR _6339_/Y sky130_fd_sc_hd__inv_2
XFILLER_103_576 VGND VGND VPWR VPWR sky130_fd_sc_hd__decap_3
XFILLER_88_265 VGND VGND VPWR VPWR sky130_fd_sc_hd__fill_2
XFILLER_76_438 VGND VGND VPWR VPWR sky130_fd_sc_hd__decap_3
XFILLER_88_298 VGND VGND VPWR VPWR sky130_fd_sc_hd__fill_1
XFILLER_29_343 VGND VGND VPWR VPWR sky130_fd_sc_hd__decap_3
XFILLER_57_641 VGND VGND VPWR VPWR sky130_fd_sc_hd__decap_3
XFILLER_17_538 VGND VGND VPWR VPWR sky130_fd_sc_hd__decap_3
XFILLER_56_151 VGND VGND VPWR VPWR sky130_fd_sc_hd__decap_3
XFILLER_57_685 VGND VGND VPWR VPWR sky130_fd_sc_hd__decap_3
XFILLER_72_622 VGND VGND VPWR VPWR sky130_fd_sc_hd__decap_3
XFILLER_44_346 VGND VGND VPWR VPWR sky130_fd_sc_hd__decap_3
XFILLER_56_195 VGND VGND VPWR VPWR sky130_fd_sc_hd__fill_1
XFILLER_71_110 VGND VGND VPWR VPWR sky130_fd_sc_hd__fill_2
XFILLER_72_666 VGND VGND VPWR VPWR sky130_fd_sc_hd__decap_3
XFILLER_71_143 VGND VGND VPWR VPWR sky130_fd_sc_hd__decap_3
XTAP_TAPCELL_ROW_27_577 VGND VPWR sky130_fd_sc_hd__tapvpwrvgnd_1
XFILLER_12_210 VGND VGND VPWR VPWR sky130_fd_sc_hd__decap_3
XFILLER_25_582 VGND VGND VPWR VPWR sky130_fd_sc_hd__decap_3
XFILLER_40_563 VGND VGND VPWR VPWR sky130_fd_sc_hd__decap_3
XFILLER_8_203 VGND VGND VPWR VPWR sky130_fd_sc_hd__fill_1
XFILLER_12_265 VGND VGND VPWR VPWR sky130_fd_sc_hd__decap_3
XFILLER_8_236 VGND VGND VPWR VPWR sky130_fd_sc_hd__decap_3
XFILLER_60_52 VGND VGND VPWR VPWR sky130_fd_sc_hd__decap_3
XFILLER_60_85 VGND VGND VPWR VPWR sky130_fd_sc_hd__decap_3
XFILLER_99_508 VGND VGND VPWR VPWR sky130_fd_sc_hd__decap_3
XFILLER_4_475 VGND VGND VPWR VPWR sky130_fd_sc_hd__fill_1
XFILLER_4_486 VGND VGND VPWR VPWR sky130_fd_sc_hd__decap_3
XFILLER_106_392 VGND VGND VPWR VPWR sky130_fd_sc_hd__decap_3
XFILLER_79_221 VGND VGND VPWR VPWR sky130_fd_sc_hd__decap_3
XFILLER_39_129 VGND VGND VPWR VPWR sky130_fd_sc_hd__fill_2
XFILLER_79_287 VGND VGND VPWR VPWR sky130_fd_sc_hd__decap_3
XFILLER_10_6 VGND VGND VPWR VPWR sky130_fd_sc_hd__fill_1
XFILLER_47_140 VGND VGND VPWR VPWR sky130_fd_sc_hd__fill_2
XFILLER_48_663 VGND VGND VPWR VPWR sky130_fd_sc_hd__decap_3
XFILLER_94_268 VGND VGND VPWR VPWR sky130_fd_sc_hd__decap_3
XFILLER_47_151 VGND VGND VPWR VPWR sky130_fd_sc_hd__decap_3
XFILLER_63_600 VGND VGND VPWR VPWR sky130_fd_sc_hd__decap_3
XFILLER_75_460 VGND VGND VPWR VPWR sky130_fd_sc_hd__decap_3
XFILLER_35_324 VGND VGND VPWR VPWR sky130_fd_sc_hd__decap_3
XFILLER_35_346 VGND VGND VPWR VPWR sky130_fd_sc_hd__decap_3
XFILLER_63_644 VGND VGND VPWR VPWR sky130_fd_sc_hd__decap_3
XFILLER_16_560 VGND VGND VPWR VPWR sky130_fd_sc_hd__decap_3
XFILLER_63_688 VGND VGND VPWR VPWR sky130_fd_sc_hd__decap_3
XTAP_TAPCELL_ROW_85_1269 VGND VPWR sky130_fd_sc_hd__tapvpwrvgnd_1
X_5710_ _7361_/Q hold915/X _5737_/S VGND VGND VPWR VPWR _6705_/D sky130_fd_sc_hd__mux2_2
XFILLER_93_3 VGND VGND VPWR VPWR sky130_fd_sc_hd__decap_3
X_6690_ _7378_/CLK _6690_/D VGND VGND VPWR VPWR _6690_/Q sky130_fd_sc_hd__dfxtp_2
XFILLER_31_585 VGND VGND VPWR VPWR sky130_fd_sc_hd__decap_3
X_5641_ _5641_/A VGND VGND VPWR VPWR _5641_/Y sky130_fd_sc_hd__inv_2
X_5572_ hold942/X _5587_/B _4961_/C VGND VGND VPWR VPWR _7045_/D sky130_fd_sc_hd__a21o_2
X_7311_ _7311_/CLK _7311_/D _6591_/Y VGND VGND VPWR VPWR _7311_/Q sky130_fd_sc_hd__dfrtp_2
XFILLER_116_134 VGND VGND VPWR VPWR sky130_fd_sc_hd__decap_3
X_7242_ _7406_/CLK _7242_/D _6522_/Y VGND VGND VPWR VPWR _7242_/Q sky130_fd_sc_hd__dfrtp_2
XFILLER_104_307 VGND VGND VPWR VPWR sky130_fd_sc_hd__fill_1
XFILLER_104_318 VGND VGND VPWR VPWR sky130_fd_sc_hd__decap_3
XFILLER_116_178 VGND VGND VPWR VPWR sky130_fd_sc_hd__decap_3
X_4454_ _4761_/B _4761_/C _4745_/A _4762_/B VGND VGND VPWR VPWR _4454_/X sky130_fd_sc_hd__a211o_2
XTAP_TAPCELL_ROW_96_1398 VGND VPWR sky130_fd_sc_hd__tapvpwrvgnd_1
X_7173_ _7368_/CLK _7173_/D _6453_/Y VGND VGND VPWR VPWR _7173_/Q sky130_fd_sc_hd__dfrtp_2
X_4385_ _7337_/Q _3945_/S _4428_/B1 _7145_/Q VGND VGND VPWR VPWR _4385_/X sky130_fd_sc_hd__a22o_2
X_3405_ _5129_/A _3561_/B _3340_/C _4667_/B VGND VGND VPWR VPWR _3409_/D sky130_fd_sc_hd__o31a_2
XFILLER_105_15 VGND VGND VPWR VPWR sky130_fd_sc_hd__decap_3
XFILLER_98_563 VGND VGND VPWR VPWR sky130_fd_sc_hd__decap_3
XFILLER_100_513 VGND VGND VPWR VPWR sky130_fd_sc_hd__decap_3
XFILLER_105_48 VGND VGND VPWR VPWR sky130_fd_sc_hd__decap_3
XFILLER_58_427 VGND VGND VPWR VPWR sky130_fd_sc_hd__decap_3
XFILLER_58_438 VGND VGND VPWR VPWR sky130_fd_sc_hd__decap_3
XFILLER_100_557 VGND VGND VPWR VPWR sky130_fd_sc_hd__decap_3
XFILLER_39_641 VGND VGND VPWR VPWR sky130_fd_sc_hd__decap_3
XFILLER_73_408 VGND VGND VPWR VPWR sky130_fd_sc_hd__decap_3
XFILLER_85_246 VGND VGND VPWR VPWR sky130_fd_sc_hd__decap_3
X_5006_ _5114_/A _4626_/X _5003_/A _5033_/B2 VGND VGND VPWR VPWR _5006_/X sky130_fd_sc_hd__a22o_2
XFILLER_39_685 VGND VGND VPWR VPWR sky130_fd_sc_hd__decap_3
XFILLER_54_622 VGND VGND VPWR VPWR sky130_fd_sc_hd__decap_3
XFILLER_66_471 VGND VGND VPWR VPWR sky130_fd_sc_hd__decap_3
XFILLER_38_195 VGND VGND VPWR VPWR sky130_fd_sc_hd__fill_1
XFILLER_93_290 VGND VGND VPWR VPWR sky130_fd_sc_hd__decap_3
XFILLER_26_368 VGND VGND VPWR VPWR sky130_fd_sc_hd__fill_1
XFILLER_54_666 VGND VGND VPWR VPWR sky130_fd_sc_hd__decap_3
X_6957_ _6978_/CLK _6957_/D VGND VGND VPWR VPWR _6957_/Q sky130_fd_sc_hd__dfxtp_2
XTAP_TAPCELL_ROW_62_1000 VGND VPWR sky130_fd_sc_hd__tapvpwrvgnd_1
XTAP_TAPCELL_ROW_24_536 VGND VPWR sky130_fd_sc_hd__tapvpwrvgnd_1
XFILLER_22_541 VGND VGND VPWR VPWR sky130_fd_sc_hd__decap_3
X_6888_ _6954_/CLK _6888_/D VGND VGND VPWR VPWR _6888_/Q sky130_fd_sc_hd__dfxtp_2
XTAP_TAPCELL_ROW_52_878 VGND VPWR sky130_fd_sc_hd__tapvpwrvgnd_1
XFILLER_22_574 VGND VGND VPWR VPWR sky130_fd_sc_hd__decap_3
XFILLER_108_613 VGND VGND VPWR VPWR sky130_fd_sc_hd__decap_3
XFILLER_5_228 VGND VGND VPWR VPWR sky130_fd_sc_hd__decap_3
XFILLER_107_134 VGND VGND VPWR VPWR sky130_fd_sc_hd__decap_3
XFILLER_108_657 VGND VGND VPWR VPWR sky130_fd_sc_hd__decap_3
XFILLER_5_239 VGND VGND VPWR VPWR sky130_fd_sc_hd__decap_3
XFILLER_107_167 VGND VGND VPWR VPWR sky130_fd_sc_hd__fill_1
XFILLER_30_66 VGND VGND VPWR VPWR sky130_fd_sc_hd__fill_1
XFILLER_30_88 VGND VGND VPWR VPWR sky130_fd_sc_hd__fill_2
XFILLER_107_189 VGND VGND VPWR VPWR sky130_fd_sc_hd__decap_3
XFILLER_89_541 VGND VGND VPWR VPWR sky130_fd_sc_hd__decap_3
Xhold770 _6826_/Q VGND VGND VPWR VPWR _6826_/D sky130_fd_sc_hd__dlygate4sd3_1
Xhold781 _6770_/Q VGND VGND VPWR VPWR _6770_/D sky130_fd_sc_hd__dlygate4sd3_1
XFILLER_103_340 VGND VGND VPWR VPWR sky130_fd_sc_hd__decap_3
Xhold792 _6789_/Q VGND VGND VPWR VPWR _6789_/D sky130_fd_sc_hd__dlygate4sd3_1
XFILLER_1_478 VGND VGND VPWR VPWR sky130_fd_sc_hd__decap_3
XFILLER_39_53 VGND VGND VPWR VPWR sky130_fd_sc_hd__decap_3
XFILLER_76_213 VGND VGND VPWR VPWR sky130_fd_sc_hd__fill_1
XFILLER_89_585 VGND VGND VPWR VPWR sky130_fd_sc_hd__decap_3
XFILLER_45_600 VGND VGND VPWR VPWR sky130_fd_sc_hd__decap_3
XTAP_TAPCELL_ROW_4_294 VGND VPWR sky130_fd_sc_hd__tapvpwrvgnd_1
XFILLER_17_335 VGND VGND VPWR VPWR sky130_fd_sc_hd__fill_1
XFILLER_44_121 VGND VGND VPWR VPWR sky130_fd_sc_hd__fill_1
XFILLER_45_644 VGND VGND VPWR VPWR sky130_fd_sc_hd__decap_3
XFILLER_57_482 VGND VGND VPWR VPWR sky130_fd_sc_hd__decap_3
XFILLER_72_430 VGND VGND VPWR VPWR sky130_fd_sc_hd__decap_3
XFILLER_45_688 VGND VGND VPWR VPWR sky130_fd_sc_hd__decap_3
XFILLER_72_441 VGND VGND VPWR VPWR sky130_fd_sc_hd__decap_3
XFILLER_72_463 VGND VGND VPWR VPWR sky130_fd_sc_hd__fill_2
XFILLER_72_474 VGND VGND VPWR VPWR sky130_fd_sc_hd__fill_2
XFILLER_32_327 VGND VGND VPWR VPWR sky130_fd_sc_hd__decap_3
XFILLER_60_625 VGND VGND VPWR VPWR sky130_fd_sc_hd__decap_3
XFILLER_13_552 VGND VGND VPWR VPWR sky130_fd_sc_hd__decap_3
XFILLER_60_669 VGND VGND VPWR VPWR sky130_fd_sc_hd__decap_3
XFILLER_13_585 VGND VGND VPWR VPWR sky130_fd_sc_hd__decap_3
XFILLER_9_523 VGND VGND VPWR VPWR sky130_fd_sc_hd__decap_3
XFILLER_71_84 VGND VGND VPWR VPWR sky130_fd_sc_hd__decap_3
XFILLER_9_567 VGND VGND VPWR VPWR sky130_fd_sc_hd__decap_3
XFILLER_9_556 VGND VGND VPWR VPWR sky130_fd_sc_hd__decap_3
XFILLER_114_616 VGND VGND VPWR VPWR sky130_fd_sc_hd__decap_3
XFILLER_4_250 VGND VGND VPWR VPWR sky130_fd_sc_hd__fill_2
XFILLER_58_6 VGND VGND VPWR VPWR sky130_fd_sc_hd__decap_3
XFILLER_4_261 VGND VGND VPWR VPWR sky130_fd_sc_hd__decap_3
X_4170_ _4203_/A _4203_/B _4202_/A VGND VGND VPWR VPWR _4938_/B sky130_fd_sc_hd__and3_2
XFILLER_67_202 VGND VGND VPWR VPWR sky130_fd_sc_hd__decap_3
XFILLER_95_511 VGND VGND VPWR VPWR sky130_fd_sc_hd__decap_3
XFILLER_67_235 VGND VGND VPWR VPWR sky130_fd_sc_hd__decap_3
XFILLER_95_544 VGND VGND VPWR VPWR sky130_fd_sc_hd__decap_3
XFILLER_55_408 VGND VGND VPWR VPWR sky130_fd_sc_hd__decap_3
XFILLER_82_205 VGND VGND VPWR VPWR sky130_fd_sc_hd__decap_3
XFILLER_95_588 VGND VGND VPWR VPWR sky130_fd_sc_hd__decap_3
XFILLER_35_110 VGND VGND VPWR VPWR sky130_fd_sc_hd__fill_2
XFILLER_36_622 VGND VGND VPWR VPWR sky130_fd_sc_hd__decap_3
XFILLER_75_290 VGND VGND VPWR VPWR sky130_fd_sc_hd__decap_3
XFILLER_23_305 VGND VGND VPWR VPWR sky130_fd_sc_hd__decap_3
XFILLER_35_143 VGND VGND VPWR VPWR sky130_fd_sc_hd__fill_1
XFILLER_36_666 VGND VGND VPWR VPWR sky130_fd_sc_hd__decap_3
XFILLER_51_603 VGND VGND VPWR VPWR sky130_fd_sc_hd__decap_3
Xplace430 _4348_/A2 VGND VGND VPWR VPWR _4459_/C1 sky130_fd_sc_hd__buf_2
X_6811_ _6954_/CLK _6811_/D VGND VGND VPWR VPWR _6811_/Q sky130_fd_sc_hd__dfxtp_2
XFILLER_35_187 VGND VGND VPWR VPWR sky130_fd_sc_hd__fill_1
XFILLER_51_647 VGND VGND VPWR VPWR sky130_fd_sc_hd__decap_3
XFILLER_63_496 VGND VGND VPWR VPWR sky130_fd_sc_hd__fill_2
XFILLER_90_293 VGND VGND VPWR VPWR sky130_fd_sc_hd__fill_2
Xplace441 _5647_/A VGND VGND VPWR VPWR _5587_/B sky130_fd_sc_hd__buf_2
Xplace452 _6981_/Q VGND VGND VPWR VPWR _3371_/A sky130_fd_sc_hd__buf_2
XFILLER_16_390 VGND VGND VPWR VPWR sky130_fd_sc_hd__decap_3
XFILLER_50_157 VGND VGND VPWR VPWR sky130_fd_sc_hd__decap_3
X_6742_ clkload9/A _6742_/D VGND VGND VPWR VPWR _6742_/Q sky130_fd_sc_hd__dfxtp_2
X_3954_ _7363_/Q _4497_/A0 _3954_/S VGND VGND VPWR VPWR _7363_/D sky130_fd_sc_hd__mux2_2
X_6673_ _6673_/A VGND VGND VPWR VPWR _6673_/Y sky130_fd_sc_hd__inv_2
X_3885_ _3746_/X _3882_/X _3884_/X _3725_/X VGND VGND VPWR VPWR _3885_/X sky130_fd_sc_hd__a22o_2
XTAP_TAPCELL_ROW_21_506 VGND VPWR sky130_fd_sc_hd__tapvpwrvgnd_1
XFILLER_31_393 VGND VGND VPWR VPWR sky130_fd_sc_hd__fill_2
X_5624_ _5624_/A _5633_/B VGND VGND VPWR VPWR _7016_/D sky130_fd_sc_hd__or2_2
XTAP_TAPCELL_ROW_98_1427 VGND VPWR sky130_fd_sc_hd__tapvpwrvgnd_1
XFILLER_105_638 VGND VGND VPWR VPWR sky130_fd_sc_hd__decap_3
X_7225_ _7322_/CLK _7225_/D _6505_/Y VGND VGND VPWR VPWR _7225_/Q sky130_fd_sc_hd__dfrtp_2
X_4437_ _7022_/Q _4437_/A2 _4437_/B1 _7399_/Q _4436_/X VGND VGND VPWR VPWR _4437_/X
+ sky130_fd_sc_hd__a221o_2
X_7156_ _7349_/CLK _7156_/D _6436_/Y VGND VGND VPWR VPWR _7156_/Q sky130_fd_sc_hd__dfrtp_2
XFILLER_113_671 VGND VGND VPWR VPWR sky130_fd_sc_hd__fill_1
XFILLER_113_682 VGND VGND VPWR VPWR sky130_fd_sc_hd__decap_3
XFILLER_116_69 VGND VGND VPWR VPWR sky130_fd_sc_hd__decap_3
XFILLER_58_224 VGND VGND VPWR VPWR sky130_fd_sc_hd__fill_1
XFILLER_76_29 VGND VGND VPWR VPWR sky130_fd_sc_hd__decap_3
XFILLER_86_533 VGND VGND VPWR VPWR sky130_fd_sc_hd__decap_3
X_4368_ _5073_/A _4366_/X _5054_/A VGND VGND VPWR VPWR _4369_/B sky130_fd_sc_hd__a21oi_2
XFILLER_100_321 VGND VGND VPWR VPWR sky130_fd_sc_hd__decap_3
XFILLER_112_192 VGND VGND VPWR VPWR sky130_fd_sc_hd__decap_3
XFILLER_86_566 VGND VGND VPWR VPWR sky130_fd_sc_hd__decap_3
X_7087_ _7349_/CLK _7087_/D _6367_/Y VGND VGND VPWR VPWR _7087_/Q sky130_fd_sc_hd__dfstp_2
X_4299_ _3620_/A _4292_/X _4298_/X VGND VGND VPWR VPWR _5100_/B sky130_fd_sc_hd__a21o_2
X_3319_ _3378_/A _5646_/A _5647_/A _5647_/B VGND VGND VPWR VPWR _3319_/X sky130_fd_sc_hd__and4b_4
XFILLER_100_354 VGND VGND VPWR VPWR sky130_fd_sc_hd__decap_3
XFILLER_100_365 VGND VGND VPWR VPWR sky130_fd_sc_hd__fill_2
XFILLER_27_600 VGND VGND VPWR VPWR sky130_fd_sc_hd__decap_3
XFILLER_46_419 VGND VGND VPWR VPWR sky130_fd_sc_hd__fill_1
XTAP_TAPCELL_ROW_57_937 VGND VPWR sky130_fd_sc_hd__tapvpwrvgnd_1
XFILLER_27_644 VGND VGND VPWR VPWR sky130_fd_sc_hd__decap_3
XFILLER_66_290 VGND VGND VPWR VPWR sky130_fd_sc_hd__decap_3
XFILLER_73_249 VGND VGND VPWR VPWR sky130_fd_sc_hd__decap_3
XFILLER_92_17 VGND VGND VPWR VPWR sky130_fd_sc_hd__decap_3
XTAP_TAPCELL_ROW_107_1534 VGND VPWR sky130_fd_sc_hd__tapvpwrvgnd_1
XFILLER_27_688 VGND VGND VPWR VPWR sky130_fd_sc_hd__decap_3
XFILLER_54_463 VGND VGND VPWR VPWR sky130_fd_sc_hd__decap_3
XTAP_TAPCELL_ROW_1_264 VGND VPWR sky130_fd_sc_hd__tapvpwrvgnd_1
XFILLER_26_165 VGND VGND VPWR VPWR sky130_fd_sc_hd__decap_3
XFILLER_41_113 VGND VGND VPWR VPWR sky130_fd_sc_hd__decap_3
XFILLER_42_625 VGND VGND VPWR VPWR sky130_fd_sc_hd__decap_3
XTAP_TAPCELL_ROW_37_694 VGND VPWR sky130_fd_sc_hd__tapvpwrvgnd_1
XFILLER_42_669 VGND VGND VPWR VPWR sky130_fd_sc_hd__decap_3
XFILLER_81_293 VGND VGND VPWR VPWR sky130_fd_sc_hd__decap_3
XFILLER_10_511 VGND VGND VPWR VPWR sky130_fd_sc_hd__decap_3
XFILLER_10_533 VGND VGND VPWR VPWR sky130_fd_sc_hd__decap_3
XFILLER_10_566 VGND VGND VPWR VPWR sky130_fd_sc_hd__decap_3
XFILLER_108_421 VGND VGND VPWR VPWR sky130_fd_sc_hd__decap_3
XFILLER_6_548 VGND VGND VPWR VPWR sky130_fd_sc_hd__decap_3
XFILLER_108_454 VGND VGND VPWR VPWR sky130_fd_sc_hd__decap_3
XFILLER_108_498 VGND VGND VPWR VPWR sky130_fd_sc_hd__decap_3
XFILLER_104_660 VGND VGND VPWR VPWR sky130_fd_sc_hd__decap_3
XFILLER_1_231 VGND VGND VPWR VPWR sky130_fd_sc_hd__decap_3
XFILLER_96_319 VGND VGND VPWR VPWR sky130_fd_sc_hd__decap_3
XTAP_TAPCELL_ROW_9_364 VGND VPWR sky130_fd_sc_hd__tapvpwrvgnd_1
XFILLER_2_15 VGND VGND VPWR VPWR sky130_fd_sc_hd__decap_3
XFILLER_89_371 VGND VGND VPWR VPWR sky130_fd_sc_hd__decap_3
XFILLER_103_181 VGND VGND VPWR VPWR sky130_fd_sc_hd__fill_1
XFILLER_77_555 VGND VGND VPWR VPWR sky130_fd_sc_hd__decap_3
XFILLER_37_419 VGND VGND VPWR VPWR sky130_fd_sc_hd__decap_3
XFILLER_77_588 VGND VGND VPWR VPWR sky130_fd_sc_hd__decap_3
XFILLER_17_110 VGND VGND VPWR VPWR sky130_fd_sc_hd__fill_2
XFILLER_18_622 VGND VGND VPWR VPWR sky130_fd_sc_hd__decap_3
XFILLER_57_290 VGND VGND VPWR VPWR sky130_fd_sc_hd__decap_3
XFILLER_92_536 VGND VGND VPWR VPWR sky130_fd_sc_hd__decap_3
XFILLER_18_666 VGND VGND VPWR VPWR sky130_fd_sc_hd__decap_3
XFILLER_33_603 VGND VGND VPWR VPWR sky130_fd_sc_hd__decap_3
XFILLER_45_441 VGND VGND VPWR VPWR sky130_fd_sc_hd__fill_2
XFILLER_92_569 VGND VGND VPWR VPWR sky130_fd_sc_hd__decap_3
XFILLER_82_50 VGND VGND VPWR VPWR sky130_fd_sc_hd__fill_1
XFILLER_33_647 VGND VGND VPWR VPWR sky130_fd_sc_hd__decap_3
XFILLER_82_83 VGND VGND VPWR VPWR sky130_fd_sc_hd__fill_1
XTAP_TAPCELL_ROW_82_1239 VGND VPWR sky130_fd_sc_hd__tapvpwrvgnd_1
XFILLER_20_319 VGND VGND VPWR VPWR sky130_fd_sc_hd__decap_3
XFILLER_60_477 VGND VGND VPWR VPWR sky130_fd_sc_hd__decap_3
XFILLER_13_393 VGND VGND VPWR VPWR sky130_fd_sc_hd__decap_3
X_3670_ _3682_/A _3669_/X _4791_/A1 VGND VGND VPWR VPWR _3670_/X sky130_fd_sc_hd__a21o_2
XFILLER_9_375 VGND VGND VPWR VPWR sky130_fd_sc_hd__fill_1
XFILLER_9_364 VGND VGND VPWR VPWR sky130_fd_sc_hd__fill_2
XFILLER_56_3 VGND VGND VPWR VPWR sky130_fd_sc_hd__decap_3
X_5340_ _5340_/A0 _5079_/X _5340_/S VGND VGND VPWR VPWR _7161_/D sky130_fd_sc_hd__mux2_2
XFILLER_114_413 VGND VGND VPWR VPWR sky130_fd_sc_hd__decap_3
XFILLER_114_424 VGND VGND VPWR VPWR sky130_fd_sc_hd__decap_3
XFILLER_5_570 VGND VGND VPWR VPWR sky130_fd_sc_hd__decap_3
XTAP_TAPCELL_ROW_93_1368 VGND VPWR sky130_fd_sc_hd__tapvpwrvgnd_1
XFILLER_99_113 VGND VGND VPWR VPWR sky130_fd_sc_hd__decap_3
XFILLER_102_619 VGND VGND VPWR VPWR sky130_fd_sc_hd__decap_3
XFILLER_114_457 VGND VGND VPWR VPWR sky130_fd_sc_hd__decap_3
XFILLER_87_308 VGND VGND VPWR VPWR sky130_fd_sc_hd__fill_2
X_7010_ _7403_/CLK _7010_/D _6290_/Y VGND VGND VPWR VPWR _7010_/Q sky130_fd_sc_hd__dfrtp_2
X_4222_ _7356_/Q _4312_/B _4221_/X VGND VGND VPWR VPWR _4222_/X sky130_fd_sc_hd__a21o_2
XFILLER_68_500 VGND VGND VPWR VPWR sky130_fd_sc_hd__decap_3
XFILLER_68_511 VGND VGND VPWR VPWR sky130_fd_sc_hd__decap_3
X_4153_ _7298_/Q _4979_/S _4267_/B1 _7170_/Q _4152_/X VGND VGND VPWR VPWR _4153_/X
+ sky130_fd_sc_hd__a221o_2
XFILLER_110_663 VGND VGND VPWR VPWR sky130_fd_sc_hd__decap_3
XFILLER_68_577 VGND VGND VPWR VPWR sky130_fd_sc_hd__decap_3
X_4084_ _7302_/Q _4491_/S _4083_/X _4429_/C1 VGND VGND VPWR VPWR _4084_/X sky130_fd_sc_hd__a211o_2
XFILLER_55_238 VGND VGND VPWR VPWR sky130_fd_sc_hd__decap_3
XFILLER_55_249 VGND VGND VPWR VPWR sky130_fd_sc_hd__decap_3
XFILLER_83_547 VGND VGND VPWR VPWR sky130_fd_sc_hd__decap_3
XFILLER_36_441 VGND VGND VPWR VPWR sky130_fd_sc_hd__fill_1
XFILLER_48_290 VGND VGND VPWR VPWR sky130_fd_sc_hd__decap_3
XFILLER_23_113 VGND VGND VPWR VPWR sky130_fd_sc_hd__decap_3
XFILLER_24_625 VGND VGND VPWR VPWR sky130_fd_sc_hd__decap_3
XFILLER_91_591 VGND VGND VPWR VPWR sky130_fd_sc_hd__decap_3
XFILLER_24_669 VGND VGND VPWR VPWR sky130_fd_sc_hd__decap_3
XFILLER_51_433 VGND VGND VPWR VPWR sky130_fd_sc_hd__fill_1
Xplace282 _3879_/A2 VGND VGND VPWR VPWR _3888_/A2 sky130_fd_sc_hd__buf_2
Xplace271 _3665_/X VGND VGND VPWR VPWR _3852_/B1 sky130_fd_sc_hd__buf_2
X_4986_ _5003_/A _5003_/B _4626_/X VGND VGND VPWR VPWR _4987_/B sky130_fd_sc_hd__a21oi_2
XFILLER_51_466 VGND VGND VPWR VPWR sky130_fd_sc_hd__decap_3
Xplace293 _3913_/B1 VGND VGND VPWR VPWR _3903_/B1 sky130_fd_sc_hd__buf_2
X_6725_ clkload7/A _6725_/D VGND VGND VPWR VPWR _6725_/Q sky130_fd_sc_hd__dfxtp_2
X_3937_ _7371_/Q _4480_/A0 _3945_/S VGND VGND VPWR VPWR _7371_/D sky130_fd_sc_hd__mux2_2
XTAP_TAPCELL_ROW_62_995 VGND VPWR sky130_fd_sc_hd__tapvpwrvgnd_1
XTAP_TAPCELL_ROW_34_664 VGND VPWR sky130_fd_sc_hd__tapvpwrvgnd_1
XTAP_TAPCELL_ROW_102_1475 VGND VPWR sky130_fd_sc_hd__tapvpwrvgnd_1
XFILLER_109_207 VGND VGND VPWR VPWR sky130_fd_sc_hd__decap_3
X_6656_ _6667_/A VGND VGND VPWR VPWR _6656_/Y sky130_fd_sc_hd__inv_2
X_3868_ _3868_/A1 _5104_/A _3867_/X VGND VGND VPWR VPWR _7384_/D sky130_fd_sc_hd__a21o_2
X_6587_ _6622_/A VGND VGND VPWR VPWR _6587_/Y sky130_fd_sc_hd__inv_2
X_5607_ _5607_/A _5634_/B VGND VGND VPWR VPWR _7024_/D sky130_fd_sc_hd__and2_2
X_3799_ _6909_/Q _3892_/A2 _3878_/A2 _6853_/Q VGND VGND VPWR VPWR _3799_/X sky130_fd_sc_hd__a22o_2
XFILLER_3_529 VGND VGND VPWR VPWR sky130_fd_sc_hd__decap_3
XFILLER_105_468 VGND VGND VPWR VPWR sky130_fd_sc_hd__decap_3
X_7208_ _7368_/CLK _7208_/D _6488_/Y VGND VGND VPWR VPWR _7208_/Q sky130_fd_sc_hd__dfrtp_2
XFILLER_59_511 VGND VGND VPWR VPWR sky130_fd_sc_hd__decap_3
XTAP_TAPCELL_ROW_6_323 VGND VPWR sky130_fd_sc_hd__tapvpwrvgnd_1
XFILLER_101_641 VGND VGND VPWR VPWR sky130_fd_sc_hd__decap_3
XFILLER_86_341 VGND VGND VPWR VPWR sky130_fd_sc_hd__decap_3
X_7139_ _7365_/CLK _7139_/D _6419_/Y VGND VGND VPWR VPWR _7139_/Q sky130_fd_sc_hd__dfrtp_2
XFILLER_101_685 VGND VGND VPWR VPWR sky130_fd_sc_hd__decap_3
XFILLER_19_419 VGND VGND VPWR VPWR sky130_fd_sc_hd__decap_3
XFILLER_46_205 VGND VGND VPWR VPWR sky130_fd_sc_hd__decap_3
XFILLER_59_588 VGND VGND VPWR VPWR sky130_fd_sc_hd__decap_3
XFILLER_86_374 VGND VGND VPWR VPWR sky130_fd_sc_hd__fill_1
XFILLER_46_249 VGND VGND VPWR VPWR sky130_fd_sc_hd__decap_3
XFILLER_74_536 VGND VGND VPWR VPWR sky130_fd_sc_hd__decap_3
XFILLER_15_603 VGND VGND VPWR VPWR sky130_fd_sc_hd__decap_3
XFILLER_27_430 VGND VGND VPWR VPWR sky130_fd_sc_hd__decap_3
XFILLER_27_441 VGND VGND VPWR VPWR sky130_fd_sc_hd__decap_3
XFILLER_74_569 VGND VGND VPWR VPWR sky130_fd_sc_hd__decap_3
XFILLER_42_411 VGND VGND VPWR VPWR sky130_fd_sc_hd__decap_3
XTAP_TAPCELL_ROW_68_1072 VGND VPWR sky130_fd_sc_hd__tapvpwrvgnd_1
XFILLER_15_647 VGND VGND VPWR VPWR sky130_fd_sc_hd__decap_3
XFILLER_42_433 VGND VGND VPWR VPWR sky130_fd_sc_hd__decap_3
XFILLER_42_455 VGND VGND VPWR VPWR sky130_fd_sc_hd__decap_3
XFILLER_14_168 VGND VGND VPWR VPWR sky130_fd_sc_hd__decap_3
XFILLER_30_628 VGND VGND VPWR VPWR sky130_fd_sc_hd__decap_3
XFILLER_10_352 VGND VGND VPWR VPWR sky130_fd_sc_hd__decap_3
XFILLER_10_374 VGND VGND VPWR VPWR sky130_fd_sc_hd__fill_2
XFILLER_10_385 VGND VGND VPWR VPWR sky130_fd_sc_hd__fill_1
XFILLER_6_312 VGND VGND VPWR VPWR sky130_fd_sc_hd__decap_3
XFILLER_6_378 VGND VGND VPWR VPWR sky130_fd_sc_hd__fill_2
XFILLER_108_273 VGND VGND VPWR VPWR sky130_fd_sc_hd__fill_1
XFILLER_2_551 VGND VGND VPWR VPWR sky130_fd_sc_hd__decap_3
XFILLER_97_617 VGND VGND VPWR VPWR sky130_fd_sc_hd__decap_3
XFILLER_97_606 VGND VGND VPWR VPWR sky130_fd_sc_hd__decap_3
XFILLER_111_405 VGND VGND VPWR VPWR sky130_fd_sc_hd__decap_3
XFILLER_2_584 VGND VGND VPWR VPWR sky130_fd_sc_hd__decap_3
XFILLER_96_105 VGND VGND VPWR VPWR sky130_fd_sc_hd__decap_3
XFILLER_111_438 VGND VGND VPWR VPWR sky130_fd_sc_hd__decap_3
XFILLER_111_449 VGND VGND VPWR VPWR sky130_fd_sc_hd__decap_3
XFILLER_2_595 VGND VGND VPWR VPWR sky130_fd_sc_hd__decap_3
XFILLER_77_330 VGND VGND VPWR VPWR sky130_fd_sc_hd__decap_3
XFILLER_65_514 VGND VGND VPWR VPWR sky130_fd_sc_hd__decap_3
XFILLER_77_374 VGND VGND VPWR VPWR sky130_fd_sc_hd__fill_1
XFILLER_77_94 VGND VGND VPWR VPWR sky130_fd_sc_hd__decap_3
XFILLER_77_396 VGND VGND VPWR VPWR sky130_fd_sc_hd__fill_2
XFILLER_65_558 VGND VGND VPWR VPWR sky130_fd_sc_hd__fill_2
XFILLER_92_355 VGND VGND VPWR VPWR sky130_fd_sc_hd__decap_3
XFILLER_18_485 VGND VGND VPWR VPWR sky130_fd_sc_hd__fill_2
XFILLER_52_219 VGND VGND VPWR VPWR sky130_fd_sc_hd__decap_3
XFILLER_80_539 VGND VGND VPWR VPWR sky130_fd_sc_hd__decap_3
XFILLER_73_591 VGND VGND VPWR VPWR sky130_fd_sc_hd__decap_3
X_4840_ _4903_/B _4903_/C _4903_/A VGND VGND VPWR VPWR _4888_/B sky130_fd_sc_hd__a21oi_2
XFILLER_21_606 VGND VGND VPWR VPWR sky130_fd_sc_hd__decap_3
XFILLER_21_617 VGND VGND VPWR VPWR sky130_fd_sc_hd__decap_3
XFILLER_33_477 VGND VGND VPWR VPWR sky130_fd_sc_hd__fill_2
XFILLER_20_127 VGND VGND VPWR VPWR sky130_fd_sc_hd__decap_3
XFILLER_60_285 VGND VGND VPWR VPWR sky130_fd_sc_hd__decap_3
X_6510_ _6638_/A VGND VGND VPWR VPWR _6510_/Y sky130_fd_sc_hd__inv_2
X_4771_ _5040_/S _7005_/D _4760_/Y _4770_/X VGND VGND VPWR VPWR _4771_/X sky130_fd_sc_hd__o211a_2
XTAP_TAPCELL_ROW_31_623 VGND VPWR sky130_fd_sc_hd__tapvpwrvgnd_1
X_6441_ _6638_/A VGND VGND VPWR VPWR _6441_/Y sky130_fd_sc_hd__inv_2
X_6372_ _6566_/A VGND VGND VPWR VPWR _6372_/Y sky130_fd_sc_hd__inv_2
XTAP_TAPCELL_ROW_11_380 VGND VPWR sky130_fd_sc_hd__tapvpwrvgnd_1
X_5323_ _5323_/A0 _4945_/X _5323_/S VGND VGND VPWR VPWR _7169_/D sky130_fd_sc_hd__mux2_2
X_3584_ _3424_/S _3583_/X _5648_/B VGND VGND VPWR VPWR _3586_/D sky130_fd_sc_hd__a21oi_2
XFILLER_87_116 VGND VGND VPWR VPWR sky130_fd_sc_hd__fill_2
XFILLER_87_127 VGND VGND VPWR VPWR sky130_fd_sc_hd__decap_3
XFILLER_88_628 VGND VGND VPWR VPWR sky130_fd_sc_hd__decap_3
X_4205_ _4205_/A _4205_/B _4205_/C VGND VGND VPWR VPWR _4205_/X sky130_fd_sc_hd__and3_2
XFILLER_110_460 VGND VGND VPWR VPWR sky130_fd_sc_hd__decap_3
XFILLER_83_300 VGND VGND VPWR VPWR sky130_fd_sc_hd__decap_3
XFILLER_96_672 VGND VGND VPWR VPWR sky130_fd_sc_hd__decap_3
X_4136_ _7235_/Q _4433_/B _4823_/S _7299_/Q _4135_/X VGND VGND VPWR VPWR _4136_/X
+ sky130_fd_sc_hd__a221o_2
XFILLER_113_26 VGND VGND VPWR VPWR sky130_fd_sc_hd__decap_3
XFILLER_28_227 VGND VGND VPWR VPWR sky130_fd_sc_hd__decap_3
XFILLER_56_536 VGND VGND VPWR VPWR sky130_fd_sc_hd__decap_3
XFILLER_83_322 VGND VGND VPWR VPWR sky130_fd_sc_hd__decap_3
XTAP_TAPCELL_ROW_39_723 VGND VPWR sky130_fd_sc_hd__tapvpwrvgnd_1
XFILLER_56_558 VGND VGND VPWR VPWR sky130_fd_sc_hd__decap_3
X_4067_ _4068_/A _4082_/A VGND VGND VPWR VPWR _4744_/B sky130_fd_sc_hd__and2_2
XTAP_TAPCELL_ROW_104_1504 VGND VPWR sky130_fd_sc_hd__tapvpwrvgnd_1
XTAP_TAPCELL_ROW_19_480 VGND VPWR sky130_fd_sc_hd__tapvpwrvgnd_1
XFILLER_12_628 VGND VGND VPWR VPWR sky130_fd_sc_hd__decap_3
XFILLER_24_477 VGND VGND VPWR VPWR sky130_fd_sc_hd__fill_1
XFILLER_51_263 VGND VGND VPWR VPWR sky130_fd_sc_hd__decap_3
XFILLER_11_116 VGND VGND VPWR VPWR sky130_fd_sc_hd__fill_2
XFILLER_11_138 VGND VGND VPWR VPWR sky130_fd_sc_hd__decap_3
X_4969_ _4968_/Y _4969_/B _4969_/C VGND VGND VPWR VPWR _4969_/X sky130_fd_sc_hd__and3b_2
X_6708_ _6941_/CLK _6708_/D VGND VGND VPWR VPWR _6708_/Q sky130_fd_sc_hd__dfxtp_2
XFILLER_20_672 VGND VGND VPWR VPWR sky130_fd_sc_hd__decap_3
X_6639_ _6640_/A VGND VGND VPWR VPWR _6639_/Y sky130_fd_sc_hd__inv_2
XFILLER_105_210 VGND VGND VPWR VPWR sky130_fd_sc_hd__decap_3
XFILLER_3_315 VGND VGND VPWR VPWR sky130_fd_sc_hd__decap_3
XTAP_TAPCELL_ROW_115_1633 VGND VPWR sky130_fd_sc_hd__tapvpwrvgnd_1
XFILLER_79_606 VGND VGND VPWR VPWR sky130_fd_sc_hd__decap_3
XFILLER_79_617 VGND VGND VPWR VPWR sky130_fd_sc_hd__decap_3
Xoutput480 _5653_/Y VGND VGND VPWR VPWR alu_result_out[29] sky130_fd_sc_hd__clkdlybuf4s25_1
XFILLER_78_127 VGND VGND VPWR VPWR sky130_fd_sc_hd__decap_3
Xoutput491 _3378_/A VGND VGND VPWR VPWR instruction_out[10] sky130_fd_sc_hd__clkdlybuf4s25_1
XPHY_EDGE_ROW_110_Right_110 VGND VGND VPWR VPWR sky130_fd_sc_hd__decap_3
XFILLER_101_460 VGND VGND VPWR VPWR sky130_fd_sc_hd__decap_3
XFILLER_47_503 VGND VGND VPWR VPWR sky130_fd_sc_hd__fill_1
XFILLER_87_650 VGND VGND VPWR VPWR sky130_fd_sc_hd__decap_3
XFILLER_47_53 VGND VGND VPWR VPWR sky130_fd_sc_hd__decap_3
XFILLER_59_396 VGND VGND VPWR VPWR sky130_fd_sc_hd__decap_3
XFILLER_74_300 VGND VGND VPWR VPWR sky130_fd_sc_hd__decap_3
XFILLER_74_333 VGND VGND VPWR VPWR sky130_fd_sc_hd__decap_3
XFILLER_86_171 VGND VGND VPWR VPWR sky130_fd_sc_hd__decap_3
XFILLER_86_193 VGND VGND VPWR VPWR sky130_fd_sc_hd__decap_3
XFILLER_27_271 VGND VGND VPWR VPWR sky130_fd_sc_hd__decap_3
XFILLER_62_517 VGND VGND VPWR VPWR sky130_fd_sc_hd__decap_3
XFILLER_62_539 VGND VGND VPWR VPWR sky130_fd_sc_hd__fill_1
XFILLER_103_81 VGND VGND VPWR VPWR sky130_fd_sc_hd__decap_3
XFILLER_27_293 VGND VGND VPWR VPWR sky130_fd_sc_hd__decap_3
XFILLER_42_230 VGND VGND VPWR VPWR sky130_fd_sc_hd__decap_3
XFILLER_55_591 VGND VGND VPWR VPWR sky130_fd_sc_hd__decap_3
XFILLER_63_30 VGND VGND VPWR VPWR sky130_fd_sc_hd__decap_3
XFILLER_70_561 VGND VGND VPWR VPWR sky130_fd_sc_hd__decap_3
XFILLER_42_285 VGND VGND VPWR VPWR sky130_fd_sc_hd__decap_3
XFILLER_11_650 VGND VGND VPWR VPWR sky130_fd_sc_hd__decap_3
XFILLER_7_632 VGND VGND VPWR VPWR sky130_fd_sc_hd__decap_3
XFILLER_10_171 VGND VGND VPWR VPWR sky130_fd_sc_hd__fill_1
XFILLER_10_193 VGND VGND VPWR VPWR sky130_fd_sc_hd__decap_3
XFILLER_116_508 VGND VGND VPWR VPWR sky130_fd_sc_hd__decap_3
XFILLER_7_665 VGND VGND VPWR VPWR sky130_fd_sc_hd__decap_3
XFILLER_7_676 VGND VGND VPWR VPWR sky130_fd_sc_hd__decap_3
XFILLER_109_582 VGND VGND VPWR VPWR sky130_fd_sc_hd__decap_3
XTAP_TAPCELL_ROW_90_1327 VGND VPWR sky130_fd_sc_hd__tapvpwrvgnd_1
XFILLER_85_609 VGND VGND VPWR VPWR sky130_fd_sc_hd__decap_3
XFILLER_78_672 VGND VGND VPWR VPWR sky130_fd_sc_hd__decap_3
XFILLER_19_3 VGND VGND VPWR VPWR sky130_fd_sc_hd__decap_3
XFILLER_65_300 VGND VGND VPWR VPWR sky130_fd_sc_hd__decap_3
XFILLER_93_620 VGND VGND VPWR VPWR sky130_fd_sc_hd__decap_3
XFILLER_38_569 VGND VGND VPWR VPWR sky130_fd_sc_hd__decap_3
XFILLER_65_333 VGND VGND VPWR VPWR sky130_fd_sc_hd__decap_3
XFILLER_92_130 VGND VGND VPWR VPWR sky130_fd_sc_hd__decap_3
XFILLER_92_141 VGND VGND VPWR VPWR sky130_fd_sc_hd__decap_3
XFILLER_93_653 VGND VGND VPWR VPWR sky130_fd_sc_hd__decap_3
X_6990_ _7398_/CLK _6990_/D _6270_/Y VGND VGND VPWR VPWR _6990_/Q sky130_fd_sc_hd__dfrtp_2
XFILLER_18_260 VGND VGND VPWR VPWR sky130_fd_sc_hd__fill_1
XFILLER_25_208 VGND VGND VPWR VPWR sky130_fd_sc_hd__decap_3
XFILLER_65_388 VGND VGND VPWR VPWR sky130_fd_sc_hd__decap_3
XFILLER_65_399 VGND VGND VPWR VPWR sky130_fd_sc_hd__decap_3
XFILLER_80_336 VGND VGND VPWR VPWR sky130_fd_sc_hd__decap_3
XFILLER_33_252 VGND VGND VPWR VPWR sky130_fd_sc_hd__decap_3
XFILLER_61_561 VGND VGND VPWR VPWR sky130_fd_sc_hd__decap_3
XFILLER_33_296 VGND VGND VPWR VPWR sky130_fd_sc_hd__decap_3
XFILLER_61_594 VGND VGND VPWR VPWR sky130_fd_sc_hd__decap_3
X_4823_ _4823_/A0 _4822_/X _4823_/S VGND VGND VPWR VPWR _7272_/D sky130_fd_sc_hd__mux2_2
XTAP_TAPCELL_ROW_44_781 VGND VPWR sky130_fd_sc_hd__tapvpwrvgnd_1
XFILLER_21_458 VGND VGND VPWR VPWR sky130_fd_sc_hd__fill_2
X_3705_ _3705_/A0 _3704_/X _4799_/A VGND VGND VPWR VPWR _7400_/D sky130_fd_sc_hd__mux2_2
XFILLER_107_508 VGND VGND VPWR VPWR sky130_fd_sc_hd__decap_3
X_4685_ _6996_/Q _4668_/X _4928_/B _4684_/X VGND VGND VPWR VPWR _4858_/B sky130_fd_sc_hd__a31o_2
XFILLER_108_15 VGND VGND VPWR VPWR sky130_fd_sc_hd__decap_3
X_6424_ _6654_/A VGND VGND VPWR VPWR _6424_/Y sky130_fd_sc_hd__inv_2
X_3636_ _3636_/A _3636_/B VGND VGND VPWR VPWR _3636_/Y sky130_fd_sc_hd__nor2_2
XFILLER_115_541 VGND VGND VPWR VPWR sky130_fd_sc_hd__decap_3
X_6355_ _6364_/A VGND VGND VPWR VPWR _6355_/Y sky130_fd_sc_hd__inv_2
X_3567_ _7221_/Q _4284_/A2 _4300_/B _7034_/Q _3566_/X VGND VGND VPWR VPWR _3567_/X
+ sky130_fd_sc_hd__a221o_2
XFILLER_0_307 VGND VGND VPWR VPWR sky130_fd_sc_hd__fill_1
XFILLER_115_585 VGND VGND VPWR VPWR sky130_fd_sc_hd__decap_3
X_6286_ _6288_/A VGND VGND VPWR VPWR _6286_/Y sky130_fd_sc_hd__inv_2
X_5306_ _5306_/A0 _4806_/X _5323_/S VGND VGND VPWR VPWR _7177_/D sky130_fd_sc_hd__mux2_2
XFILLER_102_235 VGND VGND VPWR VPWR sky130_fd_sc_hd__decap_3
X_3498_ _3874_/A _3442_/B _3449_/B VGND VGND VPWR VPWR _5152_/B sky130_fd_sc_hd__a21oi_2
XFILLER_69_650 VGND VGND VPWR VPWR sky130_fd_sc_hd__decap_3
XFILLER_75_108 VGND VGND VPWR VPWR sky130_fd_sc_hd__decap_3
XTAP_TAPCELL_ROW_110_1574 VGND VPWR sky130_fd_sc_hd__tapvpwrvgnd_1
XFILLER_56_300 VGND VGND VPWR VPWR sky130_fd_sc_hd__decap_3
XFILLER_68_171 VGND VGND VPWR VPWR sky130_fd_sc_hd__decap_3
XFILLER_84_29 VGND VGND VPWR VPWR sky130_fd_sc_hd__decap_3
XFILLER_84_631 VGND VGND VPWR VPWR sky130_fd_sc_hd__decap_3
XFILLER_96_480 VGND VGND VPWR VPWR sky130_fd_sc_hd__decap_3
XFILLER_56_344 VGND VGND VPWR VPWR sky130_fd_sc_hd__decap_3
X_5099_ _5099_/A _5100_/A VGND VGND VPWR VPWR _5099_/X sky130_fd_sc_hd__or2_2
X_4119_ _7236_/Q _4414_/A2 _4419_/B1 _7396_/Q _4118_/X VGND VGND VPWR VPWR _4119_/X
+ sky130_fd_sc_hd__a221o_2
XFILLER_56_377 VGND VGND VPWR VPWR sky130_fd_sc_hd__decap_3
XFILLER_71_325 VGND VGND VPWR VPWR sky130_fd_sc_hd__decap_3
XFILLER_84_675 VGND VGND VPWR VPWR sky130_fd_sc_hd__decap_3
XFILLER_37_591 VGND VGND VPWR VPWR sky130_fd_sc_hd__decap_3
XTAP_TAPCELL_ROW_65_1031 VGND VPWR sky130_fd_sc_hd__tapvpwrvgnd_1
XFILLER_12_414 VGND VGND VPWR VPWR sky130_fd_sc_hd__decap_3
XFILLER_24_274 VGND VGND VPWR VPWR sky130_fd_sc_hd__decap_3
XFILLER_52_583 VGND VGND VPWR VPWR sky130_fd_sc_hd__decap_3
XFILLER_4_613 VGND VGND VPWR VPWR sky130_fd_sc_hd__decap_3
XFILLER_4_657 VGND VGND VPWR VPWR sky130_fd_sc_hd__decap_3
XTAP_TAPCELL_ROW_76_1160 VGND VPWR sky130_fd_sc_hd__tapvpwrvgnd_1
XFILLER_106_563 VGND VGND VPWR VPWR sky130_fd_sc_hd__decap_3
XFILLER_67_609 VGND VGND VPWR VPWR sky130_fd_sc_hd__decap_3
XFILLER_47_311 VGND VGND VPWR VPWR sky130_fd_sc_hd__decap_3
XFILLER_58_85 VGND VGND VPWR VPWR sky130_fd_sc_hd__fill_1
XFILLER_75_620 VGND VGND VPWR VPWR sky130_fd_sc_hd__decap_3
XFILLER_74_130 VGND VGND VPWR VPWR sky130_fd_sc_hd__decap_3
XFILLER_75_653 VGND VGND VPWR VPWR sky130_fd_sc_hd__decap_3
XFILLER_114_80 VGND VGND VPWR VPWR sky130_fd_sc_hd__decap_3
XFILLER_114_91 VGND VGND VPWR VPWR sky130_fd_sc_hd__decap_3
XFILLER_35_517 VGND VGND VPWR VPWR sky130_fd_sc_hd__decap_3
XFILLER_74_174 VGND VGND VPWR VPWR sky130_fd_sc_hd__decap_3
XFILLER_90_601 VGND VGND VPWR VPWR sky130_fd_sc_hd__decap_3
XFILLER_47_399 VGND VGND VPWR VPWR sky130_fd_sc_hd__decap_3
XFILLER_90_634 VGND VGND VPWR VPWR sky130_fd_sc_hd__decap_3
XFILLER_90_645 VGND VGND VPWR VPWR sky130_fd_sc_hd__decap_3
XFILLER_15_252 VGND VGND VPWR VPWR sky130_fd_sc_hd__fill_1
XFILLER_43_561 VGND VGND VPWR VPWR sky130_fd_sc_hd__decap_3
XFILLER_90_678 VGND VGND VPWR VPWR sky130_fd_sc_hd__decap_3
XFILLER_15_263 VGND VGND VPWR VPWR sky130_fd_sc_hd__fill_1
XFILLER_15_274 VGND VGND VPWR VPWR sky130_fd_sc_hd__decap_3
XFILLER_15_296 VGND VGND VPWR VPWR sky130_fd_sc_hd__decap_3
XFILLER_30_200 VGND VGND VPWR VPWR sky130_fd_sc_hd__fill_2
XFILLER_43_594 VGND VGND VPWR VPWR sky130_fd_sc_hd__decap_3
XFILLER_88_6 VGND VGND VPWR VPWR sky130_fd_sc_hd__decap_3
XTAP_TAPCELL_ROW_41_740 VGND VPWR sky130_fd_sc_hd__tapvpwrvgnd_1
XFILLER_30_277 VGND VGND VPWR VPWR sky130_fd_sc_hd__decap_3
XFILLER_90_83 VGND VGND VPWR VPWR sky130_fd_sc_hd__fill_1
XFILLER_30_299 VGND VGND VPWR VPWR sky130_fd_sc_hd__decap_3
XFILLER_7_462 VGND VGND VPWR VPWR sky130_fd_sc_hd__decap_3
X_4470_ _3346_/A _3927_/X _4466_/Y _4469_/X VGND VGND VPWR VPWR _4470_/X sky130_fd_sc_hd__a31o_2
XFILLER_109_390 VGND VGND VPWR VPWR sky130_fd_sc_hd__fill_2
X_3421_ _4537_/B _3421_/B _3421_/C VGND VGND VPWR VPWR _5699_/S sky130_fd_sc_hd__or3_4
X_3352_ _3420_/A _5642_/B VGND VGND VPWR VPWR _3469_/B sky130_fd_sc_hd__nor2_2
XFILLER_112_522 VGND VGND VPWR VPWR sky130_fd_sc_hd__decap_3
XFILLER_112_533 VGND VGND VPWR VPWR sky130_fd_sc_hd__decap_3
XFILLER_112_566 VGND VGND VPWR VPWR sky130_fd_sc_hd__decap_3
XFILLER_38_300 VGND VGND VPWR VPWR sky130_fd_sc_hd__fill_1
XFILLER_66_631 VGND VGND VPWR VPWR sky130_fd_sc_hd__decap_3
XFILLER_78_480 VGND VGND VPWR VPWR sky130_fd_sc_hd__decap_3
Xhold1107 _7178_/Q VGND VGND VPWR VPWR _5304_/A0 sky130_fd_sc_hd__dlygate4sd3_1
Xhold1118 _7171_/Q VGND VGND VPWR VPWR _5319_/A0 sky130_fd_sc_hd__dlygate4sd3_1
Xhold1129 _7293_/Q VGND VGND VPWR VPWR _4575_/A sky130_fd_sc_hd__dlygate4sd3_1
X_5022_ _3548_/X _5017_/Y _5020_/X _5021_/X VGND VGND VPWR VPWR _5661_/A sky130_fd_sc_hd__o211a_2
XFILLER_78_491 VGND VGND VPWR VPWR sky130_fd_sc_hd__decap_3
XTAP_TAPCELL_ROW_49_840 VGND VPWR sky130_fd_sc_hd__tapvpwrvgnd_1
XFILLER_53_314 VGND VGND VPWR VPWR sky130_fd_sc_hd__decap_3
XFILLER_66_675 VGND VGND VPWR VPWR sky130_fd_sc_hd__decap_3
XFILLER_81_612 VGND VGND VPWR VPWR sky130_fd_sc_hd__decap_3
XFILLER_81_623 VGND VGND VPWR VPWR sky130_fd_sc_hd__decap_3
XFILLER_19_591 VGND VGND VPWR VPWR sky130_fd_sc_hd__decap_3
XFILLER_81_656 VGND VGND VPWR VPWR sky130_fd_sc_hd__decap_3
X_6973_ _6978_/CLK _6973_/D VGND VGND VPWR VPWR _6973_/Q sky130_fd_sc_hd__dfxtp_2
XFILLER_34_550 VGND VGND VPWR VPWR sky130_fd_sc_hd__decap_3
XFILLER_53_358 VGND VGND VPWR VPWR sky130_fd_sc_hd__decap_3
XFILLER_80_144 VGND VGND VPWR VPWR sky130_fd_sc_hd__decap_3
XFILLER_110_27 VGND VGND VPWR VPWR sky130_fd_sc_hd__fill_1
XFILLER_110_38 VGND VGND VPWR VPWR sky130_fd_sc_hd__decap_3
XFILLER_34_583 VGND VGND VPWR VPWR sky130_fd_sc_hd__decap_3
XFILLER_21_255 VGND VGND VPWR VPWR sky130_fd_sc_hd__decap_3
X_4806_ _3346_/A _3701_/X _4799_/X _4805_/X VGND VGND VPWR VPWR _4806_/X sky130_fd_sc_hd__a31o_2
X_4737_ _7005_/Q _4775_/A _7006_/Q VGND VGND VPWR VPWR _4738_/B sky130_fd_sc_hd__a21oi_2
XFILLER_107_316 VGND VGND VPWR VPWR sky130_fd_sc_hd__decap_3
X_4668_ _4908_/A _4896_/A VGND VGND VPWR VPWR _4668_/X sky130_fd_sc_hd__and2_2
XFILLER_107_349 VGND VGND VPWR VPWR sky130_fd_sc_hd__decap_3
Xhold930 _7032_/Q VGND VGND VPWR VPWR _5591_/A sky130_fd_sc_hd__dlygate4sd3_1
X_6407_ _6633_/A VGND VGND VPWR VPWR _6407_/Y sky130_fd_sc_hd__inv_2
X_3619_ _3620_/A _3620_/C _4292_/B VGND VGND VPWR VPWR _3619_/Y sky130_fd_sc_hd__o21ai_2
XFILLER_88_200 VGND VGND VPWR VPWR sky130_fd_sc_hd__decap_3
X_7387_ _7398_/CLK _7387_/D _6667_/Y VGND VGND VPWR VPWR _7387_/Q sky130_fd_sc_hd__dfrtp_2
Xhold963 _7381_/Q VGND VGND VPWR VPWR hold963/X sky130_fd_sc_hd__dlygate4sd3_1
Xhold952 _7053_/Q VGND VGND VPWR VPWR hold952/X sky130_fd_sc_hd__dlygate4sd3_1
Xhold941 _7041_/Q VGND VGND VPWR VPWR hold941/X sky130_fd_sc_hd__dlygate4sd3_1
X_4599_ _7281_/Q _5142_/A0 _4599_/S VGND VGND VPWR VPWR _4599_/X sky130_fd_sc_hd__mux2_2
XFILLER_103_511 VGND VGND VPWR VPWR sky130_fd_sc_hd__decap_3
XFILLER_103_544 VGND VGND VPWR VPWR sky130_fd_sc_hd__decap_3
XFILLER_115_393 VGND VGND VPWR VPWR sky130_fd_sc_hd__decap_3
XFILLER_1_638 VGND VGND VPWR VPWR sky130_fd_sc_hd__decap_3
XFILLER_88_211 VGND VGND VPWR VPWR sky130_fd_sc_hd__decap_3
Xhold996 _7258_/Q VGND VGND VPWR VPWR hold996/X sky130_fd_sc_hd__dlygate4sd3_1
Xhold985 _7375_/Q VGND VGND VPWR VPWR hold985/X sky130_fd_sc_hd__dlygate4sd3_1
Xhold974 _7394_/Q VGND VGND VPWR VPWR hold974/X sky130_fd_sc_hd__dlygate4sd3_1
X_6338_ _6625_/A VGND VGND VPWR VPWR _6338_/Y sky130_fd_sc_hd__inv_2
XFILLER_49_609 VGND VGND VPWR VPWR sky130_fd_sc_hd__decap_3
XFILLER_95_17 VGND VGND VPWR VPWR sky130_fd_sc_hd__decap_3
X_6269_ _6364_/A VGND VGND VPWR VPWR _6269_/Y sky130_fd_sc_hd__inv_2
XFILLER_103_588 VGND VGND VPWR VPWR sky130_fd_sc_hd__decap_3
XFILLER_57_620 VGND VGND VPWR VPWR sky130_fd_sc_hd__decap_3
XFILLER_29_355 VGND VGND VPWR VPWR sky130_fd_sc_hd__decap_3
XFILLER_57_653 VGND VGND VPWR VPWR sky130_fd_sc_hd__decap_3
XFILLER_28_99 VGND VGND VPWR VPWR sky130_fd_sc_hd__decap_3
XFILLER_29_388 VGND VGND VPWR VPWR sky130_fd_sc_hd__decap_3
XFILLER_56_141 VGND VGND VPWR VPWR sky130_fd_sc_hd__fill_1
XFILLER_72_601 VGND VGND VPWR VPWR sky130_fd_sc_hd__decap_3
XFILLER_44_325 VGND VGND VPWR VPWR sky130_fd_sc_hd__fill_1
XFILLER_71_122 VGND VGND VPWR VPWR sky130_fd_sc_hd__decap_3
XFILLER_72_634 VGND VGND VPWR VPWR sky130_fd_sc_hd__decap_3
XFILLER_72_645 VGND VGND VPWR VPWR sky130_fd_sc_hd__decap_3
XFILLER_25_561 VGND VGND VPWR VPWR sky130_fd_sc_hd__decap_3
XFILLER_44_21 VGND VGND VPWR VPWR sky130_fd_sc_hd__decap_3
XFILLER_44_358 VGND VGND VPWR VPWR sky130_fd_sc_hd__decap_3
XFILLER_71_166 VGND VGND VPWR VPWR sky130_fd_sc_hd__fill_2
XFILLER_72_678 VGND VGND VPWR VPWR sky130_fd_sc_hd__decap_3
XTAP_TAPCELL_ROW_27_578 VGND VPWR sky130_fd_sc_hd__tapvpwrvgnd_1
XFILLER_12_200 VGND VGND VPWR VPWR sky130_fd_sc_hd__decap_3
XFILLER_25_594 VGND VGND VPWR VPWR sky130_fd_sc_hd__decap_3
XFILLER_12_222 VGND VGND VPWR VPWR sky130_fd_sc_hd__decap_3
XFILLER_40_531 VGND VGND VPWR VPWR sky130_fd_sc_hd__fill_1
XFILLER_44_98 VGND VGND VPWR VPWR sky130_fd_sc_hd__decap_3
XFILLER_12_288 VGND VGND VPWR VPWR sky130_fd_sc_hd__decap_3
XFILLER_40_575 VGND VGND VPWR VPWR sky130_fd_sc_hd__decap_3
XFILLER_8_248 VGND VGND VPWR VPWR sky130_fd_sc_hd__decap_3
XFILLER_5_15 VGND VGND VPWR VPWR sky130_fd_sc_hd__decap_3
XFILLER_4_498 VGND VGND VPWR VPWR sky130_fd_sc_hd__decap_3
XFILLER_0_660 VGND VGND VPWR VPWR sky130_fd_sc_hd__decap_3
XFILLER_0_682 VGND VGND VPWR VPWR sky130_fd_sc_hd__decap_3
XFILLER_67_428 VGND VGND VPWR VPWR sky130_fd_sc_hd__decap_3
XFILLER_79_299 VGND VGND VPWR VPWR sky130_fd_sc_hd__decap_3
XFILLER_48_631 VGND VGND VPWR VPWR sky130_fd_sc_hd__decap_3
XPHY_EDGE_ROW_13_Right_13 VGND VGND VPWR VPWR sky130_fd_sc_hd__decap_3
XFILLER_47_163 VGND VGND VPWR VPWR sky130_fd_sc_hd__decap_3
XFILLER_48_675 VGND VGND VPWR VPWR sky130_fd_sc_hd__decap_3
XFILLER_63_612 VGND VGND VPWR VPWR sky130_fd_sc_hd__decap_3
XFILLER_63_623 VGND VGND VPWR VPWR sky130_fd_sc_hd__decap_3
XFILLER_63_656 VGND VGND VPWR VPWR sky130_fd_sc_hd__decap_3
XFILLER_90_431 VGND VGND VPWR VPWR sky130_fd_sc_hd__decap_3
XFILLER_35_358 VGND VGND VPWR VPWR sky130_fd_sc_hd__decap_3
XFILLER_50_306 VGND VGND VPWR VPWR sky130_fd_sc_hd__fill_2
XFILLER_90_464 VGND VGND VPWR VPWR sky130_fd_sc_hd__decap_3
X_3970_ _7355_/Q _4513_/A0 _3989_/S VGND VGND VPWR VPWR _7355_/D sky130_fd_sc_hd__mux2_2
XFILLER_16_572 VGND VGND VPWR VPWR sky130_fd_sc_hd__decap_3
XFILLER_31_564 VGND VGND VPWR VPWR sky130_fd_sc_hd__decap_3
X_5640_ _5642_/A _5640_/B VGND VGND VPWR VPWR _5640_/Y sky130_fd_sc_hd__nor2_2
XFILLER_31_597 VGND VGND VPWR VPWR sky130_fd_sc_hd__decap_3
X_5571_ hold938/X _4960_/A _4944_/C VGND VGND VPWR VPWR _7046_/D sky130_fd_sc_hd__a21o_2
XPHY_EDGE_ROW_22_Right_22 VGND VGND VPWR VPWR sky130_fd_sc_hd__decap_3
XFILLER_116_113 VGND VGND VPWR VPWR sky130_fd_sc_hd__decap_3
X_7310_ _7374_/CLK _7310_/D _6590_/Y VGND VGND VPWR VPWR _7310_/Q sky130_fd_sc_hd__dfrtp_2
X_4522_ _4522_/A0 _4589_/A _4528_/B VGND VGND VPWR VPWR _7318_/D sky130_fd_sc_hd__mux2_2
XFILLER_7_281 VGND VGND VPWR VPWR sky130_fd_sc_hd__decap_3
XFILLER_7_292 VGND VGND VPWR VPWR sky130_fd_sc_hd__decap_3
X_7241_ _7405_/CLK _7241_/D _6521_/Y VGND VGND VPWR VPWR _7241_/Q sky130_fd_sc_hd__dfrtp_2
X_4453_ _4453_/A VGND VGND VPWR VPWR _4762_/B sky130_fd_sc_hd__inv_2
XTAP_TAPCELL_ROW_96_1399 VGND VPWR sky130_fd_sc_hd__tapvpwrvgnd_1
X_7172_ _7364_/CLK _7172_/D _6452_/Y VGND VGND VPWR VPWR _7172_/Q sky130_fd_sc_hd__dfrtp_2
X_4384_ _4384_/A _4968_/A _4384_/C VGND VGND VPWR VPWR _4778_/B sky130_fd_sc_hd__nand3_2
XFILLER_98_542 VGND VGND VPWR VPWR sky130_fd_sc_hd__decap_3
XFILLER_98_531 VGND VGND VPWR VPWR sky130_fd_sc_hd__fill_1
X_3335_ _3319_/X _5238_/B _3329_/Y _3339_/C1 VGND VGND VPWR VPWR _3874_/A sky130_fd_sc_hd__a211o_2
XFILLER_98_575 VGND VGND VPWR VPWR sky130_fd_sc_hd__decap_3
XFILLER_100_525 VGND VGND VPWR VPWR sky130_fd_sc_hd__decap_3
XFILLER_100_536 VGND VGND VPWR VPWR sky130_fd_sc_hd__decap_3
XFILLER_105_27 VGND VGND VPWR VPWR sky130_fd_sc_hd__decap_3
XFILLER_112_385 VGND VGND VPWR VPWR sky130_fd_sc_hd__decap_3
XFILLER_39_620 VGND VGND VPWR VPWR sky130_fd_sc_hd__decap_3
XFILLER_58_417 VGND VGND VPWR VPWR sky130_fd_sc_hd__decap_3
XFILLER_85_203 VGND VGND VPWR VPWR sky130_fd_sc_hd__decap_3
XPHY_EDGE_ROW_31_Right_31 VGND VGND VPWR VPWR sky130_fd_sc_hd__decap_3
XFILLER_100_569 VGND VGND VPWR VPWR sky130_fd_sc_hd__decap_3
XFILLER_39_653 VGND VGND VPWR VPWR sky130_fd_sc_hd__decap_3
XFILLER_85_258 VGND VGND VPWR VPWR sky130_fd_sc_hd__decap_3
X_5005_ _5004_/A _5004_/B _5020_/A VGND VGND VPWR VPWR _5005_/Y sky130_fd_sc_hd__a21oi_2
XFILLER_26_303 VGND VGND VPWR VPWR sky130_fd_sc_hd__decap_3
XFILLER_38_141 VGND VGND VPWR VPWR sky130_fd_sc_hd__decap_3
XFILLER_54_601 VGND VGND VPWR VPWR sky130_fd_sc_hd__decap_3
XFILLER_66_461 VGND VGND VPWR VPWR sky130_fd_sc_hd__fill_2
XFILLER_26_347 VGND VGND VPWR VPWR sky130_fd_sc_hd__decap_3
XFILLER_54_634 VGND VGND VPWR VPWR sky130_fd_sc_hd__decap_3
XFILLER_54_645 VGND VGND VPWR VPWR sky130_fd_sc_hd__decap_3
XFILLER_81_420 VGND VGND VPWR VPWR sky130_fd_sc_hd__decap_3
XFILLER_53_166 VGND VGND VPWR VPWR sky130_fd_sc_hd__fill_2
XFILLER_54_678 VGND VGND VPWR VPWR sky130_fd_sc_hd__decap_3
X_6956_ _6968_/CLK _6956_/D VGND VGND VPWR VPWR _6956_/Q sky130_fd_sc_hd__dfxtp_2
XTAP_TAPCELL_ROW_62_1001 VGND VPWR sky130_fd_sc_hd__tapvpwrvgnd_1
XFILLER_22_553 VGND VGND VPWR VPWR sky130_fd_sc_hd__decap_3
X_6887_ _6943_/CLK _6887_/D VGND VGND VPWR VPWR _6887_/Q sky130_fd_sc_hd__dfxtp_2
XTAP_TAPCELL_ROW_24_537 VGND VPWR sky130_fd_sc_hd__tapvpwrvgnd_1
XFILLER_22_586 VGND VGND VPWR VPWR sky130_fd_sc_hd__fill_2
XTAP_TAPCELL_ROW_52_879 VGND VPWR sky130_fd_sc_hd__tapvpwrvgnd_1
XPHY_EDGE_ROW_40_Right_40 VGND VGND VPWR VPWR sky130_fd_sc_hd__decap_3
XFILLER_108_625 VGND VGND VPWR VPWR sky130_fd_sc_hd__decap_3
XFILLER_107_146 VGND VGND VPWR VPWR sky130_fd_sc_hd__decap_3
XFILLER_108_669 VGND VGND VPWR VPWR sky130_fd_sc_hd__decap_3
Xhold760 _6965_/Q VGND VGND VPWR VPWR _6965_/D sky130_fd_sc_hd__dlygate4sd3_1
Xhold771 _6930_/Q VGND VGND VPWR VPWR _6930_/D sky130_fd_sc_hd__dlygate4sd3_1
Xhold782 _6959_/Q VGND VGND VPWR VPWR _6959_/D sky130_fd_sc_hd__dlygate4sd3_1
XTAP_TAPCELL_ROW_73_1130 VGND VPWR sky130_fd_sc_hd__tapvpwrvgnd_1
XFILLER_115_190 VGND VGND VPWR VPWR sky130_fd_sc_hd__fill_2
XFILLER_1_457 VGND VGND VPWR VPWR sky130_fd_sc_hd__decap_3
XFILLER_89_553 VGND VGND VPWR VPWR sky130_fd_sc_hd__decap_3
XFILLER_89_564 VGND VGND VPWR VPWR sky130_fd_sc_hd__decap_3
Xhold793 _6943_/Q VGND VGND VPWR VPWR _6943_/D sky130_fd_sc_hd__dlygate4sd3_1
XFILLER_103_363 VGND VGND VPWR VPWR sky130_fd_sc_hd__decap_3
XFILLER_76_203 VGND VGND VPWR VPWR sky130_fd_sc_hd__decap_3
XFILLER_89_597 VGND VGND VPWR VPWR sky130_fd_sc_hd__decap_3
XFILLER_103_396 VGND VGND VPWR VPWR sky130_fd_sc_hd__decap_3
XFILLER_76_236 VGND VGND VPWR VPWR sky130_fd_sc_hd__decap_3
XFILLER_45_612 VGND VGND VPWR VPWR sky130_fd_sc_hd__decap_3
XFILLER_64_409 VGND VGND VPWR VPWR sky130_fd_sc_hd__decap_3
XFILLER_76_269 VGND VGND VPWR VPWR sky130_fd_sc_hd__decap_3
XFILLER_91_206 VGND VGND VPWR VPWR sky130_fd_sc_hd__decap_3
XFILLER_45_623 VGND VGND VPWR VPWR sky130_fd_sc_hd__decap_3
XFILLER_84_280 VGND VGND VPWR VPWR sky130_fd_sc_hd__decap_3
XTAP_TAPCELL_ROW_4_295 VGND VPWR sky130_fd_sc_hd__tapvpwrvgnd_1
XFILLER_45_656 VGND VGND VPWR VPWR sky130_fd_sc_hd__decap_3
XFILLER_60_604 VGND VGND VPWR VPWR sky130_fd_sc_hd__decap_3
XFILLER_60_637 VGND VGND VPWR VPWR sky130_fd_sc_hd__decap_3
XFILLER_60_648 VGND VGND VPWR VPWR sky130_fd_sc_hd__decap_3
XFILLER_13_531 VGND VGND VPWR VPWR sky130_fd_sc_hd__decap_3
XFILLER_13_564 VGND VGND VPWR VPWR sky130_fd_sc_hd__decap_3
XFILLER_40_350 VGND VGND VPWR VPWR sky130_fd_sc_hd__decap_3
XFILLER_71_52 VGND VGND VPWR VPWR sky130_fd_sc_hd__decap_3
XFILLER_9_535 VGND VGND VPWR VPWR sky130_fd_sc_hd__decap_3
XFILLER_13_597 VGND VGND VPWR VPWR sky130_fd_sc_hd__decap_3
XFILLER_72_9 VGND VGND VPWR VPWR sky130_fd_sc_hd__decap_3
XFILLER_9_579 VGND VGND VPWR VPWR sky130_fd_sc_hd__decap_3
XFILLER_114_628 VGND VGND VPWR VPWR sky130_fd_sc_hd__decap_3
XFILLER_99_317 VGND VGND VPWR VPWR sky130_fd_sc_hd__decap_3
XFILLER_4_273 VGND VGND VPWR VPWR sky130_fd_sc_hd__fill_2
XFILLER_67_214 VGND VGND VPWR VPWR sky130_fd_sc_hd__decap_3
XFILLER_95_523 VGND VGND VPWR VPWR sky130_fd_sc_hd__decap_3
XFILLER_96_60 VGND VGND VPWR VPWR sky130_fd_sc_hd__decap_3
XFILLER_95_556 VGND VGND VPWR VPWR sky130_fd_sc_hd__decap_3
XFILLER_95_567 VGND VGND VPWR VPWR sky130_fd_sc_hd__decap_3
XFILLER_96_93 VGND VGND VPWR VPWR sky130_fd_sc_hd__decap_3
XFILLER_36_601 VGND VGND VPWR VPWR sky130_fd_sc_hd__decap_3
XFILLER_82_217 VGND VGND VPWR VPWR sky130_fd_sc_hd__fill_2
XFILLER_36_634 VGND VGND VPWR VPWR sky130_fd_sc_hd__decap_3
XFILLER_36_645 VGND VGND VPWR VPWR sky130_fd_sc_hd__decap_3
XFILLER_48_483 VGND VGND VPWR VPWR sky130_fd_sc_hd__fill_1
XFILLER_63_431 VGND VGND VPWR VPWR sky130_fd_sc_hd__decap_3
XFILLER_82_239 VGND VGND VPWR VPWR sky130_fd_sc_hd__decap_3
XFILLER_36_678 VGND VGND VPWR VPWR sky130_fd_sc_hd__decap_3
XFILLER_90_250 VGND VGND VPWR VPWR sky130_fd_sc_hd__fill_2
Xplace420 _4390_/B1 VGND VGND VPWR VPWR _3945_/S sky130_fd_sc_hd__buf_2
Xplace431 _4318_/B1 VGND VGND VPWR VPWR _4348_/A2 sky130_fd_sc_hd__buf_2
X_6810_ clkload9/A _6810_/D VGND VGND VPWR VPWR _6810_/Q sky130_fd_sc_hd__dfxtp_2
XFILLER_23_317 VGND VGND VPWR VPWR sky130_fd_sc_hd__decap_3
XFILLER_23_328 VGND VGND VPWR VPWR sky130_fd_sc_hd__decap_3
XFILLER_51_615 VGND VGND VPWR VPWR sky130_fd_sc_hd__fill_1
XFILLER_51_626 VGND VGND VPWR VPWR sky130_fd_sc_hd__decap_3
Xplace442 _5647_/A VGND VGND VPWR VPWR _4960_/A sky130_fd_sc_hd__buf_2
Xplace453 _6981_/Q VGND VGND VPWR VPWR _3324_/A sky130_fd_sc_hd__buf_2
XFILLER_35_199 VGND VGND VPWR VPWR sky130_fd_sc_hd__decap_3
XFILLER_51_659 VGND VGND VPWR VPWR sky130_fd_sc_hd__decap_3
X_6741_ clkload6/A _6741_/D VGND VGND VPWR VPWR _6741_/Q sky130_fd_sc_hd__dfxtp_2
XFILLER_31_350 VGND VGND VPWR VPWR sky130_fd_sc_hd__decap_3
X_6672_ _6672_/A VGND VGND VPWR VPWR _6672_/Y sky130_fd_sc_hd__inv_2
X_3884_ _6824_/Q _3926_/A2 _3889_/B1 _6809_/Q _3883_/X VGND VGND VPWR VPWR _3884_/X
+ sky130_fd_sc_hd__a221o_2
XTAP_TAPCELL_ROW_21_507 VGND VPWR sky130_fd_sc_hd__tapvpwrvgnd_1
XTAP_TAPCELL_ROW_98_1428 VGND VPWR sky130_fd_sc_hd__tapvpwrvgnd_1
XFILLER_105_606 VGND VGND VPWR VPWR sky130_fd_sc_hd__decap_3
XFILLER_105_617 VGND VGND VPWR VPWR sky130_fd_sc_hd__decap_3
X_4505_ _4505_/A0 _7295_/Q _4505_/S VGND VGND VPWR VPWR _7327_/D sky130_fd_sc_hd__mux2_2
XFILLER_104_105 VGND VGND VPWR VPWR sky130_fd_sc_hd__decap_3
XFILLER_116_15 VGND VGND VPWR VPWR sky130_fd_sc_hd__decap_3
X_7224_ _7355_/CLK _7224_/D _6504_/Y VGND VGND VPWR VPWR _7224_/Q sky130_fd_sc_hd__dfrtp_2
X_4436_ _7303_/Q _4946_/S _4436_/B1 _7175_/Q _4435_/X VGND VGND VPWR VPWR _4436_/X
+ sky130_fd_sc_hd__a221o_2
XFILLER_113_650 VGND VGND VPWR VPWR sky130_fd_sc_hd__decap_3
XFILLER_116_37 VGND VGND VPWR VPWR sky130_fd_sc_hd__decap_3
X_7155_ _7350_/CLK _7155_/D _6435_/Y VGND VGND VPWR VPWR _7155_/Q sky130_fd_sc_hd__dfrtp_2
X_4367_ _4367_/A _4367_/B _4367_/C VGND VGND VPWR VPWR _5054_/A sky130_fd_sc_hd__and3_2
X_3318_ _3403_/A _3332_/B VGND VGND VPWR VPWR _5647_/B sky130_fd_sc_hd__nand2_2
XFILLER_100_333 VGND VGND VPWR VPWR sky130_fd_sc_hd__decap_3
XFILLER_86_545 VGND VGND VPWR VPWR sky130_fd_sc_hd__decap_3
X_7086_ _7403_/CLK _7086_/D _6366_/Y VGND VGND VPWR VPWR _7086_/Q sky130_fd_sc_hd__dfrtp_2
X_4298_ _3620_/C _4292_/X _4293_/X _4297_/Y VGND VGND VPWR VPWR _4298_/X sky130_fd_sc_hd__a211o_2
XFILLER_27_612 VGND VGND VPWR VPWR sky130_fd_sc_hd__decap_3
XFILLER_73_206 VGND VGND VPWR VPWR sky130_fd_sc_hd__decap_3
XFILLER_86_578 VGND VGND VPWR VPWR sky130_fd_sc_hd__decap_3
XFILLER_86_589 VGND VGND VPWR VPWR sky130_fd_sc_hd__decap_3
XFILLER_27_623 VGND VGND VPWR VPWR sky130_fd_sc_hd__decap_3
XFILLER_73_239 VGND VGND VPWR VPWR sky130_fd_sc_hd__decap_3
XTAP_TAPCELL_ROW_57_938 VGND VPWR sky130_fd_sc_hd__tapvpwrvgnd_1
XFILLER_27_656 VGND VGND VPWR VPWR sky130_fd_sc_hd__decap_3
XFILLER_42_604 VGND VGND VPWR VPWR sky130_fd_sc_hd__decap_3
XFILLER_92_29 VGND VGND VPWR VPWR sky130_fd_sc_hd__decap_3
XTAP_TAPCELL_ROW_1_265 VGND VPWR sky130_fd_sc_hd__tapvpwrvgnd_1
XTAP_TAPCELL_ROW_107_1535 VGND VPWR sky130_fd_sc_hd__tapvpwrvgnd_1
XFILLER_25_45 VGND VGND VPWR VPWR sky130_fd_sc_hd__decap_3
XFILLER_42_637 VGND VGND VPWR VPWR sky130_fd_sc_hd__decap_3
XFILLER_54_475 VGND VGND VPWR VPWR sky130_fd_sc_hd__fill_1
XFILLER_42_648 VGND VGND VPWR VPWR sky130_fd_sc_hd__decap_3
X_6939_ _7405_/CLK _6939_/D VGND VGND VPWR VPWR _6939_/Q sky130_fd_sc_hd__dfxtp_2
XTAP_TAPCELL_ROW_37_695 VGND VPWR sky130_fd_sc_hd__tapvpwrvgnd_1
XFILLER_41_169 VGND VGND VPWR VPWR sky130_fd_sc_hd__decap_3
XFILLER_10_523 VGND VGND VPWR VPWR sky130_fd_sc_hd__decap_3
XFILLER_50_681 VGND VGND VPWR VPWR sky130_fd_sc_hd__decap_3
XFILLER_10_545 VGND VGND VPWR VPWR sky130_fd_sc_hd__decap_3
XFILLER_10_578 VGND VGND VPWR VPWR sky130_fd_sc_hd__decap_3
XFILLER_6_516 VGND VGND VPWR VPWR sky130_fd_sc_hd__decap_3
XFILLER_108_433 VGND VGND VPWR VPWR sky130_fd_sc_hd__decap_3
XFILLER_10_589 VGND VGND VPWR VPWR sky130_fd_sc_hd__decap_3
XFILLER_108_466 VGND VGND VPWR VPWR sky130_fd_sc_hd__decap_3
XFILLER_108_477 VGND VGND VPWR VPWR sky130_fd_sc_hd__decap_3
XFILLER_111_609 VGND VGND VPWR VPWR sky130_fd_sc_hd__decap_3
XFILLER_89_350 VGND VGND VPWR VPWR sky130_fd_sc_hd__decap_3
XFILLER_96_309 VGND VGND VPWR VPWR sky130_fd_sc_hd__decap_3
Xhold590 _6896_/Q VGND VGND VPWR VPWR _6896_/D sky130_fd_sc_hd__dlygate4sd3_1
XTAP_TAPCELL_ROW_9_365 VGND VPWR sky130_fd_sc_hd__tapvpwrvgnd_1
XTAP_TAPCELL_ROW_9_354 VGND VPWR sky130_fd_sc_hd__tapvpwrvgnd_1
XFILLER_104_672 VGND VGND VPWR VPWR sky130_fd_sc_hd__decap_3
XFILLER_77_501 VGND VGND VPWR VPWR sky130_fd_sc_hd__decap_3
XFILLER_89_383 VGND VGND VPWR VPWR sky130_fd_sc_hd__decap_3
XFILLER_49_225 VGND VGND VPWR VPWR sky130_fd_sc_hd__decap_3
XFILLER_18_601 VGND VGND VPWR VPWR sky130_fd_sc_hd__decap_3
XFILLER_77_567 VGND VGND VPWR VPWR sky130_fd_sc_hd__decap_3
XFILLER_18_634 VGND VGND VPWR VPWR sky130_fd_sc_hd__decap_3
XFILLER_18_645 VGND VGND VPWR VPWR sky130_fd_sc_hd__decap_3
XFILLER_92_526 VGND VGND VPWR VPWR sky130_fd_sc_hd__decap_3
XFILLER_92_548 VGND VGND VPWR VPWR sky130_fd_sc_hd__decap_3
XFILLER_17_122 VGND VGND VPWR VPWR sky130_fd_sc_hd__fill_2
XFILLER_18_678 VGND VGND VPWR VPWR sky130_fd_sc_hd__decap_3
XFILLER_33_615 VGND VGND VPWR VPWR sky130_fd_sc_hd__fill_1
XFILLER_33_626 VGND VGND VPWR VPWR sky130_fd_sc_hd__decap_3
XFILLER_45_475 VGND VGND VPWR VPWR sky130_fd_sc_hd__decap_3
XFILLER_33_659 VGND VGND VPWR VPWR sky130_fd_sc_hd__decap_3
XFILLER_60_456 VGND VGND VPWR VPWR sky130_fd_sc_hd__decap_3
XFILLER_13_361 VGND VGND VPWR VPWR sky130_fd_sc_hd__fill_2
XFILLER_20_309 VGND VGND VPWR VPWR sky130_fd_sc_hd__fill_2
XFILLER_9_310 VGND VGND VPWR VPWR sky130_fd_sc_hd__decap_3
XFILLER_70_6 VGND VGND VPWR VPWR sky130_fd_sc_hd__decap_3
XFILLER_114_436 VGND VGND VPWR VPWR sky130_fd_sc_hd__decap_3
XFILLER_5_582 VGND VGND VPWR VPWR sky130_fd_sc_hd__decap_3
X_5270_ _5270_/A0 _5040_/X _5286_/S VGND VGND VPWR VPWR _7195_/D sky130_fd_sc_hd__mux2_2
XFILLER_114_469 VGND VGND VPWR VPWR sky130_fd_sc_hd__decap_3
XFILLER_49_3 VGND VGND VPWR VPWR sky130_fd_sc_hd__decap_3
X_4221_ _7228_/Q _4414_/A2 _4269_/B1 _7041_/Q _4220_/X VGND VGND VPWR VPWR _4221_/X
+ sky130_fd_sc_hd__a221o_2
XTAP_TAPCELL_ROW_93_1369 VGND VPWR sky130_fd_sc_hd__tapvpwrvgnd_1
XFILLER_101_108 VGND VGND VPWR VPWR sky130_fd_sc_hd__decap_3
XFILLER_68_523 VGND VGND VPWR VPWR sky130_fd_sc_hd__decap_3
XFILLER_110_631 VGND VGND VPWR VPWR sky130_fd_sc_hd__decap_3
X_4152_ _7106_/Q _4351_/A2 _4267_/A2 _7138_/Q VGND VGND VPWR VPWR _4152_/X sky130_fd_sc_hd__a22o_2
XFILLER_110_675 VGND VGND VPWR VPWR sky130_fd_sc_hd__decap_3
XFILLER_68_589 VGND VGND VPWR VPWR sky130_fd_sc_hd__decap_3
X_4083_ _7366_/Q _4419_/B1 _4348_/A2 _7174_/Q VGND VGND VPWR VPWR _4083_/X sky130_fd_sc_hd__a22o_2
XFILLER_55_217 VGND VGND VPWR VPWR sky130_fd_sc_hd__decap_3
XFILLER_55_228 VGND VGND VPWR VPWR sky130_fd_sc_hd__fill_1
XFILLER_83_526 VGND VGND VPWR VPWR sky130_fd_sc_hd__decap_3
XFILLER_102_17 VGND VGND VPWR VPWR sky130_fd_sc_hd__decap_3
XFILLER_36_431 VGND VGND VPWR VPWR sky130_fd_sc_hd__fill_1
XFILLER_36_453 VGND VGND VPWR VPWR sky130_fd_sc_hd__fill_1
XFILLER_83_559 VGND VGND VPWR VPWR sky130_fd_sc_hd__fill_1
XFILLER_24_604 VGND VGND VPWR VPWR sky130_fd_sc_hd__decap_3
XFILLER_24_637 VGND VGND VPWR VPWR sky130_fd_sc_hd__decap_3
XFILLER_51_412 VGND VGND VPWR VPWR sky130_fd_sc_hd__decap_3
XFILLER_63_261 VGND VGND VPWR VPWR sky130_fd_sc_hd__decap_3
XFILLER_91_570 VGND VGND VPWR VPWR sky130_fd_sc_hd__decap_3
XFILLER_24_648 VGND VGND VPWR VPWR sky130_fd_sc_hd__decap_3
Xplace272 _3902_/B1 VGND VGND VPWR VPWR _3925_/B1 sky130_fd_sc_hd__buf_2
X_4985_ _4620_/A _5032_/A _5031_/B _4630_/X VGND VGND VPWR VPWR _5003_/B sky130_fd_sc_hd__a31o_2
XFILLER_51_478 VGND VGND VPWR VPWR sky130_fd_sc_hd__fill_1
Xplace294 _5660_/B VGND VGND VPWR VPWR _3913_/B1 sky130_fd_sc_hd__buf_2
Xplace283 _3921_/A2 VGND VGND VPWR VPWR _3918_/A2 sky130_fd_sc_hd__buf_2
X_6724_ _6974_/CLK _6724_/D VGND VGND VPWR VPWR _6724_/Q sky130_fd_sc_hd__dfxtp_2
XTAP_TAPCELL_ROW_34_665 VGND VPWR sky130_fd_sc_hd__tapvpwrvgnd_1
XTAP_TAPCELL_ROW_34_654 VGND VPWR sky130_fd_sc_hd__tapvpwrvgnd_1
XFILLER_32_681 VGND VGND VPWR VPWR sky130_fd_sc_hd__decap_3
XTAP_TAPCELL_ROW_62_996 VGND VPWR sky130_fd_sc_hd__tapvpwrvgnd_1
XTAP_TAPCELL_ROW_102_1476 VGND VPWR sky130_fd_sc_hd__tapvpwrvgnd_1
XFILLER_109_219 VGND VGND VPWR VPWR sky130_fd_sc_hd__decap_3
XFILLER_31_180 VGND VGND VPWR VPWR sky130_fd_sc_hd__fill_2
X_6655_ _6667_/A VGND VGND VPWR VPWR _6655_/Y sky130_fd_sc_hd__inv_2
X_3867_ _3629_/Y _3866_/X _5151_/A VGND VGND VPWR VPWR _3867_/X sky130_fd_sc_hd__o21a_2
X_6586_ _6586_/A VGND VGND VPWR VPWR _6586_/Y sky130_fd_sc_hd__inv_2
X_3798_ _6738_/Q _3879_/B1 _3892_/B1 _6744_/Q _3797_/X VGND VGND VPWR VPWR _3798_/X
+ sky130_fd_sc_hd__a221o_2
XFILLER_3_508 VGND VGND VPWR VPWR sky130_fd_sc_hd__decap_3
XFILLER_105_403 VGND VGND VPWR VPWR sky130_fd_sc_hd__decap_3
XFILLER_2_9 VGND VGND VPWR VPWR sky130_fd_sc_hd__decap_3
XFILLER_78_309 VGND VGND VPWR VPWR sky130_fd_sc_hd__decap_3
X_7207_ _7403_/CLK _7207_/D _6487_/Y VGND VGND VPWR VPWR _7207_/Q sky130_fd_sc_hd__dfrtp_2
X_4419_ _7304_/Q _4491_/S _4419_/B1 _7368_/Q _4429_/C1 VGND VGND VPWR VPWR _4419_/X
+ sky130_fd_sc_hd__a221o_2
XTAP_TAPCELL_ROW_6_324 VGND VPWR sky130_fd_sc_hd__tapvpwrvgnd_1
XFILLER_101_620 VGND VGND VPWR VPWR sky130_fd_sc_hd__decap_3
XFILLER_113_491 VGND VGND VPWR VPWR sky130_fd_sc_hd__decap_3
X_7138_ _7332_/CLK _7138_/D _6418_/Y VGND VGND VPWR VPWR _7138_/Q sky130_fd_sc_hd__dfrtp_2
XFILLER_98_191 VGND VGND VPWR VPWR sky130_fd_sc_hd__decap_3
XFILLER_101_653 VGND VGND VPWR VPWR sky130_fd_sc_hd__decap_3
XFILLER_59_567 VGND VGND VPWR VPWR sky130_fd_sc_hd__decap_3
XFILLER_86_353 VGND VGND VPWR VPWR sky130_fd_sc_hd__decap_3
X_7069_ _7344_/CLK _7069_/D _6349_/Y VGND VGND VPWR VPWR _7069_/Q sky130_fd_sc_hd__dfrtp_2
XFILLER_100_163 VGND VGND VPWR VPWR sky130_fd_sc_hd__decap_3
XFILLER_46_228 VGND VGND VPWR VPWR sky130_fd_sc_hd__decap_3
XFILLER_74_548 VGND VGND VPWR VPWR sky130_fd_sc_hd__decap_3
XFILLER_27_453 VGND VGND VPWR VPWR sky130_fd_sc_hd__fill_1
XFILLER_39_291 VGND VGND VPWR VPWR sky130_fd_sc_hd__decap_3
XFILLER_15_615 VGND VGND VPWR VPWR sky130_fd_sc_hd__fill_1
XFILLER_15_626 VGND VGND VPWR VPWR sky130_fd_sc_hd__decap_3
XFILLER_27_464 VGND VGND VPWR VPWR sky130_fd_sc_hd__decap_3
XFILLER_36_88 VGND VGND VPWR VPWR sky130_fd_sc_hd__fill_1
XFILLER_54_272 VGND VGND VPWR VPWR sky130_fd_sc_hd__decap_3
XFILLER_82_581 VGND VGND VPWR VPWR sky130_fd_sc_hd__decap_3
XTAP_TAPCELL_ROW_68_1073 VGND VPWR sky130_fd_sc_hd__tapvpwrvgnd_1
XTAP_TAPCELL_ROW_68_1062 VGND VPWR sky130_fd_sc_hd__tapvpwrvgnd_1
XFILLER_15_659 VGND VGND VPWR VPWR sky130_fd_sc_hd__decap_3
XFILLER_42_445 VGND VGND VPWR VPWR sky130_fd_sc_hd__decap_3
XFILLER_82_592 VGND VGND VPWR VPWR sky130_fd_sc_hd__decap_3
XFILLER_30_607 VGND VGND VPWR VPWR sky130_fd_sc_hd__decap_3
XFILLER_10_331 VGND VGND VPWR VPWR sky130_fd_sc_hd__decap_3
XFILLER_6_346 VGND VGND VPWR VPWR sky130_fd_sc_hd__decap_3
XFILLER_6_368 VGND VGND VPWR VPWR sky130_fd_sc_hd__fill_2
XFILLER_108_285 VGND VGND VPWR VPWR sky130_fd_sc_hd__decap_3
XFILLER_111_417 VGND VGND VPWR VPWR sky130_fd_sc_hd__decap_3
XFILLER_2_563 VGND VGND VPWR VPWR sky130_fd_sc_hd__decap_3
XFILLER_96_117 VGND VGND VPWR VPWR sky130_fd_sc_hd__decap_3
XFILLER_97_629 VGND VGND VPWR VPWR sky130_fd_sc_hd__decap_3
XFILLER_104_480 VGND VGND VPWR VPWR sky130_fd_sc_hd__decap_3
XFILLER_77_353 VGND VGND VPWR VPWR sky130_fd_sc_hd__decap_3
XFILLER_65_526 VGND VGND VPWR VPWR sky130_fd_sc_hd__decap_3
XFILLER_92_312 VGND VGND VPWR VPWR sky130_fd_sc_hd__fill_1
XFILLER_93_50 VGND VGND VPWR VPWR sky130_fd_sc_hd__decap_3
XFILLER_18_475 VGND VGND VPWR VPWR sky130_fd_sc_hd__fill_1
XFILLER_73_570 VGND VGND VPWR VPWR sky130_fd_sc_hd__decap_3
XFILLER_21_629 VGND VGND VPWR VPWR sky130_fd_sc_hd__decap_3
XFILLER_60_242 VGND VGND VPWR VPWR sky130_fd_sc_hd__fill_1
XFILLER_60_253 VGND VGND VPWR VPWR sky130_fd_sc_hd__fill_1
XFILLER_14_681 VGND VGND VPWR VPWR sky130_fd_sc_hd__decap_3
X_4770_ _4832_/A _3692_/X _5663_/A _4791_/C1 VGND VGND VPWR VPWR _4770_/X sky130_fd_sc_hd__a211o_2
XTAP_TAPCELL_ROW_31_624 VGND VPWR sky130_fd_sc_hd__tapvpwrvgnd_1
X_3721_ _6863_/Q _3889_/A2 _3889_/B1 _6855_/Q _3720_/X VGND VGND VPWR VPWR _3721_/X
+ sky130_fd_sc_hd__a221o_2
X_6440_ _6626_/A VGND VGND VPWR VPWR _6440_/Y sky130_fd_sc_hd__inv_2
X_6371_ _6566_/A VGND VGND VPWR VPWR _6371_/Y sky130_fd_sc_hd__inv_2
X_3583_ _3583_/A _3583_/B _3583_/C VGND VGND VPWR VPWR _3583_/X sky130_fd_sc_hd__or3_4
XTAP_TAPCELL_ROW_11_381 VGND VPWR sky130_fd_sc_hd__tapvpwrvgnd_1
XFILLER_9_195 VGND VGND VPWR VPWR sky130_fd_sc_hd__decap_3
XFILLER_114_200 VGND VGND VPWR VPWR sky130_fd_sc_hd__decap_3
XFILLER_5_390 VGND VGND VPWR VPWR sky130_fd_sc_hd__fill_2
XFILLER_88_607 VGND VGND VPWR VPWR sky130_fd_sc_hd__decap_3
X_5253_ _5253_/A0 _4913_/X _5262_/S VGND VGND VPWR VPWR _7203_/D sky130_fd_sc_hd__mux2_2
XFILLER_114_299 VGND VGND VPWR VPWR sky130_fd_sc_hd__fill_2
XFILLER_87_139 VGND VGND VPWR VPWR sky130_fd_sc_hd__decap_3
XFILLER_96_640 VGND VGND VPWR VPWR sky130_fd_sc_hd__decap_3
X_5184_ _5184_/A _5209_/B VGND VGND VPWR VPWR _7236_/D sky130_fd_sc_hd__and2_2
X_4204_ _4936_/A _4201_/X _4203_/X VGND VGND VPWR VPWR _4204_/Y sky130_fd_sc_hd__o21bai_2
XFILLER_96_651 VGND VGND VPWR VPWR sky130_fd_sc_hd__decap_3
X_4135_ _7107_/Q _4351_/A2 _4267_/A2 _7139_/Q VGND VGND VPWR VPWR _4135_/X sky130_fd_sc_hd__a22o_2
XFILLER_110_472 VGND VGND VPWR VPWR sky130_fd_sc_hd__decap_3
XFILLER_110_483 VGND VGND VPWR VPWR sky130_fd_sc_hd__decap_3
XFILLER_28_239 VGND VGND VPWR VPWR sky130_fd_sc_hd__decap_3
XFILLER_95_172 VGND VGND VPWR VPWR sky130_fd_sc_hd__fill_2
XFILLER_96_684 VGND VGND VPWR VPWR sky130_fd_sc_hd__decap_3
XTAP_TAPCELL_ROW_39_724 VGND VPWR sky130_fd_sc_hd__tapvpwrvgnd_1
XFILLER_113_38 VGND VGND VPWR VPWR sky130_fd_sc_hd__decap_3
X_4066_ _4062_/X _4065_/X _4425_/A VGND VGND VPWR VPWR _4082_/A sky130_fd_sc_hd__o21a_2
XFILLER_83_378 VGND VGND VPWR VPWR sky130_fd_sc_hd__decap_3
XTAP_TAPCELL_ROW_104_1505 VGND VPWR sky130_fd_sc_hd__tapvpwrvgnd_1
XFILLER_51_220 VGND VGND VPWR VPWR sky130_fd_sc_hd__decap_3
XFILLER_64_581 VGND VGND VPWR VPWR sky130_fd_sc_hd__decap_3
XFILLER_64_592 VGND VGND VPWR VPWR sky130_fd_sc_hd__decap_3
XTAP_TAPCELL_ROW_19_481 VGND VPWR sky130_fd_sc_hd__tapvpwrvgnd_1
XFILLER_12_607 VGND VGND VPWR VPWR sky130_fd_sc_hd__decap_3
XFILLER_51_242 VGND VGND VPWR VPWR sky130_fd_sc_hd__decap_3
XFILLER_51_275 VGND VGND VPWR VPWR sky130_fd_sc_hd__decap_3
X_4968_ _4968_/A _4967_/B VGND VGND VPWR VPWR _4968_/Y sky130_fd_sc_hd__nor2b_2
XFILLER_20_640 VGND VGND VPWR VPWR sky130_fd_sc_hd__decap_3
XFILLER_20_651 VGND VGND VPWR VPWR sky130_fd_sc_hd__decap_3
X_6707_ _7403_/CLK _6707_/D VGND VGND VPWR VPWR _6707_/Q sky130_fd_sc_hd__dfxtp_2
X_4899_ _5040_/S _6998_/D _5656_/B _4898_/X VGND VGND VPWR VPWR _4899_/X sky130_fd_sc_hd__o22a_2
X_3919_ _3682_/A _3918_/X _4791_/A1 VGND VGND VPWR VPWR _3919_/X sky130_fd_sc_hd__a21o_2
XFILLER_20_684 VGND VGND VPWR VPWR sky130_fd_sc_hd__decap_3
X_6638_ _6638_/A VGND VGND VPWR VPWR _6638_/Y sky130_fd_sc_hd__inv_2
X_6569_ _6569_/A VGND VGND VPWR VPWR _6569_/Y sky130_fd_sc_hd__inv_2
XTAP_TAPCELL_ROW_115_1634 VGND VPWR sky130_fd_sc_hd__tapvpwrvgnd_1
XFILLER_0_6 VGND VGND VPWR VPWR sky130_fd_sc_hd__fill_1
XFILLER_105_244 VGND VGND VPWR VPWR sky130_fd_sc_hd__fill_1
XFILLER_105_266 VGND VGND VPWR VPWR sky130_fd_sc_hd__decap_3
XFILLER_78_106 VGND VGND VPWR VPWR sky130_fd_sc_hd__fill_1
XFILLER_79_629 VGND VGND VPWR VPWR sky130_fd_sc_hd__decap_3
Xoutput470 _5659_/B VGND VGND VPWR VPWR alu_result_out[1] sky130_fd_sc_hd__clkdlybuf4s25_1
XFILLER_105_299 VGND VGND VPWR VPWR sky130_fd_sc_hd__fill_2
XFILLER_78_139 VGND VGND VPWR VPWR sky130_fd_sc_hd__fill_1
Xoutput492 _5647_/Y VGND VGND VPWR VPWR instruction_out[11] sky130_fd_sc_hd__clkdlybuf4s25_1
Xoutput481 _3634_/Y VGND VGND VPWR VPWR alu_result_out[2] sky130_fd_sc_hd__clkdlybuf4s25_1
XFILLER_87_662 VGND VGND VPWR VPWR sky130_fd_sc_hd__decap_3
XFILLER_87_673 VGND VGND VPWR VPWR sky130_fd_sc_hd__decap_3
XFILLER_93_109 VGND VGND VPWR VPWR sky130_fd_sc_hd__decap_3
XFILLER_101_483 VGND VGND VPWR VPWR sky130_fd_sc_hd__decap_3
XFILLER_47_32 VGND VGND VPWR VPWR sky130_fd_sc_hd__fill_1
XFILLER_74_312 VGND VGND VPWR VPWR sky130_fd_sc_hd__decap_3
XFILLER_47_559 VGND VGND VPWR VPWR sky130_fd_sc_hd__fill_1
XFILLER_62_507 VGND VGND VPWR VPWR sky130_fd_sc_hd__decap_3
XFILLER_74_345 VGND VGND VPWR VPWR sky130_fd_sc_hd__decap_3
XFILLER_55_570 VGND VGND VPWR VPWR sky130_fd_sc_hd__decap_3
XFILLER_62_529 VGND VGND VPWR VPWR sky130_fd_sc_hd__decap_3
XFILLER_30_404 VGND VGND VPWR VPWR sky130_fd_sc_hd__fill_2
XFILLER_42_253 VGND VGND VPWR VPWR sky130_fd_sc_hd__fill_1
XFILLER_70_540 VGND VGND VPWR VPWR sky130_fd_sc_hd__decap_3
XFILLER_70_573 VGND VGND VPWR VPWR sky130_fd_sc_hd__decap_3
XPHY_EDGE_ROW_69_Right_69 VGND VGND VPWR VPWR sky130_fd_sc_hd__decap_3
XFILLER_42_297 VGND VGND VPWR VPWR sky130_fd_sc_hd__decap_3
XFILLER_70_595 VGND VGND VPWR VPWR sky130_fd_sc_hd__decap_3
XFILLER_7_600 VGND VGND VPWR VPWR sky130_fd_sc_hd__decap_3
XFILLER_11_662 VGND VGND VPWR VPWR sky130_fd_sc_hd__decap_3
XFILLER_11_673 VGND VGND VPWR VPWR sky130_fd_sc_hd__decap_3
XFILLER_109_550 VGND VGND VPWR VPWR sky130_fd_sc_hd__decap_3
XFILLER_7_644 VGND VGND VPWR VPWR sky130_fd_sc_hd__decap_3
XFILLER_109_561 VGND VGND VPWR VPWR sky130_fd_sc_hd__decap_3
XFILLER_109_594 VGND VGND VPWR VPWR sky130_fd_sc_hd__decap_3
XFILLER_6_154 VGND VGND VPWR VPWR sky130_fd_sc_hd__fill_1
XFILLER_7_688 VGND VGND VPWR VPWR sky130_fd_sc_hd__decap_3
XPHY_EDGE_ROW_78_Right_78 VGND VGND VPWR VPWR sky130_fd_sc_hd__decap_3
XFILLER_111_203 VGND VGND VPWR VPWR sky130_fd_sc_hd__fill_1
XFILLER_69_106 VGND VGND VPWR VPWR sky130_fd_sc_hd__decap_3
XTAP_TAPCELL_ROW_90_1328 VGND VPWR sky130_fd_sc_hd__tapvpwrvgnd_1
XFILLER_111_236 VGND VGND VPWR VPWR sky130_fd_sc_hd__fill_1
XFILLER_69_128 VGND VGND VPWR VPWR sky130_fd_sc_hd__decap_3
XFILLER_88_83 VGND VGND VPWR VPWR sky130_fd_sc_hd__fill_1
XFILLER_88_94 VGND VGND VPWR VPWR sky130_fd_sc_hd__decap_3
XFILLER_111_258 VGND VGND VPWR VPWR sky130_fd_sc_hd__fill_1
XFILLER_111_269 VGND VGND VPWR VPWR sky130_fd_sc_hd__decap_3
XFILLER_78_640 VGND VGND VPWR VPWR sky130_fd_sc_hd__decap_3
XFILLER_78_651 VGND VGND VPWR VPWR sky130_fd_sc_hd__decap_3
XFILLER_77_150 VGND VGND VPWR VPWR sky130_fd_sc_hd__decap_3
XFILLER_78_684 VGND VGND VPWR VPWR sky130_fd_sc_hd__decap_3
XFILLER_93_632 VGND VGND VPWR VPWR sky130_fd_sc_hd__decap_3
XFILLER_38_548 VGND VGND VPWR VPWR sky130_fd_sc_hd__decap_3
XFILLER_93_665 VGND VGND VPWR VPWR sky130_fd_sc_hd__decap_3
XFILLER_46_570 VGND VGND VPWR VPWR sky130_fd_sc_hd__decap_3
XFILLER_93_676 VGND VGND VPWR VPWR sky130_fd_sc_hd__decap_3
XFILLER_46_592 VGND VGND VPWR VPWR sky130_fd_sc_hd__decap_3
XFILLER_80_348 VGND VGND VPWR VPWR sky130_fd_sc_hd__decap_3
XFILLER_92_197 VGND VGND VPWR VPWR sky130_fd_sc_hd__decap_3
XPHY_EDGE_ROW_87_Right_87 VGND VGND VPWR VPWR sky130_fd_sc_hd__decap_3
XFILLER_33_231 VGND VGND VPWR VPWR sky130_fd_sc_hd__decap_3
XTAP_TAPCELL_ROW_16_440 VGND VPWR sky130_fd_sc_hd__tapvpwrvgnd_1
XFILLER_33_264 VGND VGND VPWR VPWR sky130_fd_sc_hd__decap_3
XFILLER_61_573 VGND VGND VPWR VPWR sky130_fd_sc_hd__decap_3
X_4822_ _5040_/S _7002_/D _5663_/B _4821_/X VGND VGND VPWR VPWR _4822_/X sky130_fd_sc_hd__o22a_2
XTAP_TAPCELL_ROW_44_782 VGND VPWR sky130_fd_sc_hd__tapvpwrvgnd_1
X_4753_ _4753_/A0 _4752_/X _4837_/S VGND VGND VPWR VPWR _7276_/D sky130_fd_sc_hd__mux2_2
X_3704_ _6712_/Q _3917_/A2 _3902_/B1 _6890_/Q _3703_/X VGND VGND VPWR VPWR _3704_/X
+ sky130_fd_sc_hd__a221o_2
X_6423_ _6617_/A VGND VGND VPWR VPWR _6423_/Y sky130_fd_sc_hd__inv_2
X_4684_ _6996_/Q _4668_/X _4943_/A _4683_/X VGND VGND VPWR VPWR _4684_/X sky130_fd_sc_hd__a31o_2
X_3635_ _3635_/A _3635_/B _3547_/A VGND VGND VPWR VPWR _3635_/X sky130_fd_sc_hd__or3b_2
XPHY_EDGE_ROW_96_Right_96 VGND VGND VPWR VPWR sky130_fd_sc_hd__decap_3
XFILLER_108_27 VGND VGND VPWR VPWR sky130_fd_sc_hd__fill_1
XFILLER_108_38 VGND VGND VPWR VPWR sky130_fd_sc_hd__decap_3
XFILLER_115_520 VGND VGND VPWR VPWR sky130_fd_sc_hd__decap_3
X_6354_ _6642_/A VGND VGND VPWR VPWR _6354_/Y sky130_fd_sc_hd__inv_2
X_3566_ _7189_/Q _4471_/S _3380_/Y _7381_/Q VGND VGND VPWR VPWR _3566_/X sky130_fd_sc_hd__a22o_2
XFILLER_115_553 VGND VGND VPWR VPWR sky130_fd_sc_hd__decap_3
XFILLER_115_564 VGND VGND VPWR VPWR sky130_fd_sc_hd__decap_3
XFILLER_88_404 VGND VGND VPWR VPWR sky130_fd_sc_hd__decap_3
X_6285_ _6462_/A VGND VGND VPWR VPWR _6285_/Y sky130_fd_sc_hd__inv_2
X_3497_ _7151_/Q _3409_/X _3493_/X _3496_/X VGND VGND VPWR VPWR _3497_/X sky130_fd_sc_hd__a211o_2
XFILLER_115_597 VGND VGND VPWR VPWR sky130_fd_sc_hd__decap_3
X_5236_ _5236_/A0 _4752_/X _5256_/S VGND VGND VPWR VPWR _7212_/D sky130_fd_sc_hd__mux2_2
XFILLER_102_247 VGND VGND VPWR VPWR sky130_fd_sc_hd__decap_3
XFILLER_69_662 VGND VGND VPWR VPWR sky130_fd_sc_hd__decap_3
XTAP_TAPCELL_ROW_110_1575 VGND VPWR sky130_fd_sc_hd__tapvpwrvgnd_1
XFILLER_56_312 VGND VGND VPWR VPWR sky130_fd_sc_hd__decap_3
XFILLER_68_150 VGND VGND VPWR VPWR sky130_fd_sc_hd__decap_3
XFILLER_69_673 VGND VGND VPWR VPWR sky130_fd_sc_hd__decap_3
XFILLER_84_610 VGND VGND VPWR VPWR sky130_fd_sc_hd__decap_3
X_5167_ _5167_/A _5177_/B VGND VGND VPWR VPWR _7244_/D sky130_fd_sc_hd__and2_2
XPHY_EDGE_ROW_3_Left_120 VGND VGND VPWR VPWR sky130_fd_sc_hd__decap_3
XFILLER_56_356 VGND VGND VPWR VPWR sky130_fd_sc_hd__decap_3
XFILLER_68_183 VGND VGND VPWR VPWR sky130_fd_sc_hd__decap_3
XFILLER_84_643 VGND VGND VPWR VPWR sky130_fd_sc_hd__fill_1
XFILLER_84_654 VGND VGND VPWR VPWR sky130_fd_sc_hd__decap_3
X_5098_ _5098_/A _5098_/B VGND VGND VPWR VPWR _6985_/D sky130_fd_sc_hd__nor2_2
X_4118_ _7021_/Q _4422_/A2 _4093_/B _7364_/Q VGND VGND VPWR VPWR _4118_/X sky130_fd_sc_hd__a22o_2
XFILLER_37_570 VGND VGND VPWR VPWR sky130_fd_sc_hd__decap_3
XFILLER_56_389 VGND VGND VPWR VPWR sky130_fd_sc_hd__decap_3
XFILLER_71_304 VGND VGND VPWR VPWR sky130_fd_sc_hd__decap_3
XFILLER_84_687 VGND VGND VPWR VPWR sky130_fd_sc_hd__decap_3
X_4049_ _7213_/Q _3947_/S _4837_/S _7309_/Q _4048_/X VGND VGND VPWR VPWR _4049_/X
+ sky130_fd_sc_hd__a221o_2
XFILLER_17_57 VGND VGND VPWR VPWR sky130_fd_sc_hd__decap_3
XFILLER_17_68 VGND VGND VPWR VPWR sky130_fd_sc_hd__decap_3
XFILLER_24_253 VGND VGND VPWR VPWR sky130_fd_sc_hd__decap_3
XTAP_TAPCELL_ROW_65_1032 VGND VPWR sky130_fd_sc_hd__tapvpwrvgnd_1
XFILLER_24_286 VGND VGND VPWR VPWR sky130_fd_sc_hd__decap_3
XFILLER_52_595 VGND VGND VPWR VPWR sky130_fd_sc_hd__decap_3
XFILLER_33_45 VGND VGND VPWR VPWR sky130_fd_sc_hd__fill_1
XPHY_EDGE_ROW_49_Left_166 VGND VGND VPWR VPWR sky130_fd_sc_hd__decap_3
XFILLER_116_3 VGND VGND VPWR VPWR sky130_fd_sc_hd__decap_3
XFILLER_4_625 VGND VGND VPWR VPWR sky130_fd_sc_hd__decap_3
XFILLER_106_531 VGND VGND VPWR VPWR sky130_fd_sc_hd__fill_1
XFILLER_106_542 VGND VGND VPWR VPWR sky130_fd_sc_hd__decap_3
XFILLER_106_575 VGND VGND VPWR VPWR sky130_fd_sc_hd__decap_3
XFILLER_4_669 VGND VGND VPWR VPWR sky130_fd_sc_hd__decap_3
XTAP_TAPCELL_ROW_76_1161 VGND VPWR sky130_fd_sc_hd__tapvpwrvgnd_1
XFILLER_79_437 VGND VGND VPWR VPWR sky130_fd_sc_hd__decap_3
XFILLER_94_429 VGND VGND VPWR VPWR sky130_fd_sc_hd__decap_3
XPHY_EDGE_ROW_58_Left_175 VGND VGND VPWR VPWR sky130_fd_sc_hd__decap_3
XFILLER_47_323 VGND VGND VPWR VPWR sky130_fd_sc_hd__decap_3
XFILLER_75_632 VGND VGND VPWR VPWR sky130_fd_sc_hd__decap_3
XFILLER_75_665 VGND VGND VPWR VPWR sky130_fd_sc_hd__decap_3
XFILLER_75_676 VGND VGND VPWR VPWR sky130_fd_sc_hd__decap_3
XFILLER_90_613 VGND VGND VPWR VPWR sky130_fd_sc_hd__decap_3
XFILLER_28_581 VGND VGND VPWR VPWR sky130_fd_sc_hd__decap_3
XFILLER_28_592 VGND VGND VPWR VPWR sky130_fd_sc_hd__decap_3
XFILLER_74_186 VGND VGND VPWR VPWR sky130_fd_sc_hd__decap_3
XFILLER_74_197 VGND VGND VPWR VPWR sky130_fd_sc_hd__decap_3
XFILLER_74_85 VGND VGND VPWR VPWR sky130_fd_sc_hd__decap_3
XFILLER_90_657 VGND VGND VPWR VPWR sky130_fd_sc_hd__decap_3
XFILLER_15_231 VGND VGND VPWR VPWR sky130_fd_sc_hd__decap_3
XFILLER_43_551 VGND VGND VPWR VPWR sky130_fd_sc_hd__decap_3
XTAP_TAPCELL_ROW_87_1290 VGND VPWR sky130_fd_sc_hd__tapvpwrvgnd_1
XFILLER_30_212 VGND VGND VPWR VPWR sky130_fd_sc_hd__decap_3
XFILLER_43_573 VGND VGND VPWR VPWR sky130_fd_sc_hd__decap_3
XTAP_TAPCELL_ROW_41_741 VGND VPWR sky130_fd_sc_hd__tapvpwrvgnd_1
XTAP_TAPCELL_ROW_13_410 VGND VPWR sky130_fd_sc_hd__tapvpwrvgnd_1
XPHY_EDGE_ROW_67_Left_184 VGND VGND VPWR VPWR sky130_fd_sc_hd__decap_3
XFILLER_30_256 VGND VGND VPWR VPWR sky130_fd_sc_hd__decap_3
XFILLER_7_441 VGND VGND VPWR VPWR sky130_fd_sc_hd__decap_3
XFILLER_7_485 VGND VGND VPWR VPWR sky130_fd_sc_hd__fill_2
XFILLER_109_380 VGND VGND VPWR VPWR sky130_fd_sc_hd__decap_3
X_3420_ _3420_/A _5642_/B VGND VGND VPWR VPWR _3442_/B sky130_fd_sc_hd__or2_2
XFILLER_112_501 VGND VGND VPWR VPWR sky130_fd_sc_hd__decap_3
X_3351_ _5130_/A _3350_/Y _3340_/B VGND VGND VPWR VPWR _5642_/B sky130_fd_sc_hd__o21a_2
XFILLER_112_545 VGND VGND VPWR VPWR sky130_fd_sc_hd__decap_3
XFILLER_112_578 VGND VGND VPWR VPWR sky130_fd_sc_hd__decap_3
XPHY_EDGE_ROW_76_Left_193 VGND VGND VPWR VPWR sky130_fd_sc_hd__decap_3
XFILLER_112_589 VGND VGND VPWR VPWR sky130_fd_sc_hd__decap_3
XFILLER_38_312 VGND VGND VPWR VPWR sky130_fd_sc_hd__decap_3
XFILLER_57_109 VGND VGND VPWR VPWR sky130_fd_sc_hd__decap_3
XFILLER_66_610 VGND VGND VPWR VPWR sky130_fd_sc_hd__decap_3
XFILLER_85_429 VGND VGND VPWR VPWR sky130_fd_sc_hd__decap_3
Xhold1108 _7227_/Q VGND VGND VPWR VPWR _5203_/A sky130_fd_sc_hd__dlygate4sd3_1
Xhold1119 _7163_/Q VGND VGND VPWR VPWR _5336_/A0 sky130_fd_sc_hd__dlygate4sd3_1
X_5021_ _5114_/A _4372_/A _5018_/A _5101_/A VGND VGND VPWR VPWR _5021_/X sky130_fd_sc_hd__o2bb2a_2
XFILLER_66_643 VGND VGND VPWR VPWR sky130_fd_sc_hd__fill_1
XFILLER_66_654 VGND VGND VPWR VPWR sky130_fd_sc_hd__decap_3
XTAP_TAPCELL_ROW_49_841 VGND VPWR sky130_fd_sc_hd__tapvpwrvgnd_1
XFILLER_66_687 VGND VGND VPWR VPWR sky130_fd_sc_hd__decap_3
XFILLER_19_570 VGND VGND VPWR VPWR sky130_fd_sc_hd__decap_3
XFILLER_53_326 VGND VGND VPWR VPWR sky130_fd_sc_hd__fill_2
XFILLER_53_337 VGND VGND VPWR VPWR sky130_fd_sc_hd__decap_3
XFILLER_81_635 VGND VGND VPWR VPWR sky130_fd_sc_hd__decap_3
X_6972_ clkload8/A _6972_/D VGND VGND VPWR VPWR _6972_/Q sky130_fd_sc_hd__dfxtp_2
XFILLER_34_562 VGND VGND VPWR VPWR sky130_fd_sc_hd__decap_3
XFILLER_80_156 VGND VGND VPWR VPWR sky130_fd_sc_hd__decap_3
XFILLER_81_668 VGND VGND VPWR VPWR sky130_fd_sc_hd__decap_3
XFILLER_81_679 VGND VGND VPWR VPWR sky130_fd_sc_hd__decap_3
XFILLER_34_595 VGND VGND VPWR VPWR sky130_fd_sc_hd__decap_3
XFILLER_80_189 VGND VGND VPWR VPWR sky130_fd_sc_hd__decap_3
XFILLER_21_223 VGND VGND VPWR VPWR sky130_fd_sc_hd__fill_1
XFILLER_21_234 VGND VGND VPWR VPWR sky130_fd_sc_hd__decap_3
X_4805_ _4997_/A1 _7003_/D _4804_/X VGND VGND VPWR VPWR _4805_/X sky130_fd_sc_hd__a21bo_2
XFILLER_21_278 VGND VGND VPWR VPWR sky130_fd_sc_hd__fill_2
XFILLER_107_306 VGND VGND VPWR VPWR sky130_fd_sc_hd__decap_3
XFILLER_107_328 VGND VGND VPWR VPWR sky130_fd_sc_hd__fill_2
X_4667_ _6998_/Q _4667_/B VGND VGND VPWR VPWR _4896_/A sky130_fd_sc_hd__xnor2_2
X_7386_ _7398_/CLK _7386_/D _6666_/Y VGND VGND VPWR VPWR _7386_/Q sky130_fd_sc_hd__dfrtp_2
Xhold920 _6692_/Q VGND VGND VPWR VPWR hold920/X sky130_fd_sc_hd__dlygate4sd3_1
Xhold931 _7311_/Q VGND VGND VPWR VPWR hold931/X sky130_fd_sc_hd__dlygate4sd3_1
X_6406_ _6632_/A VGND VGND VPWR VPWR _6406_/Y sky130_fd_sc_hd__inv_2
X_3618_ _5118_/C _4938_/A _4764_/B VGND VGND VPWR VPWR _3618_/X sky130_fd_sc_hd__and3_2
XFILLER_103_501 VGND VGND VPWR VPWR sky130_fd_sc_hd__decap_3
XFILLER_1_617 VGND VGND VPWR VPWR sky130_fd_sc_hd__decap_3
Xhold964 _7189_/Q VGND VGND VPWR VPWR hold964/X sky130_fd_sc_hd__dlygate4sd3_1
Xhold953 _7016_/Q VGND VGND VPWR VPWR _5624_/A sky130_fd_sc_hd__dlygate4sd3_1
Xhold942 _7045_/Q VGND VGND VPWR VPWR hold942/X sky130_fd_sc_hd__dlygate4sd3_1
X_6337_ _6628_/A VGND VGND VPWR VPWR _6337_/Y sky130_fd_sc_hd__inv_2
XFILLER_103_523 VGND VGND VPWR VPWR sky130_fd_sc_hd__decap_3
XFILLER_115_383 VGND VGND VPWR VPWR sky130_fd_sc_hd__decap_3
XFILLER_88_223 VGND VGND VPWR VPWR sky130_fd_sc_hd__decap_3
Xhold997 _7190_/Q VGND VGND VPWR VPWR hold997/X sky130_fd_sc_hd__dlygate4sd3_1
Xhold986 _6694_/Q VGND VGND VPWR VPWR hold986/X sky130_fd_sc_hd__dlygate4sd3_1
Xhold975 _7022_/Q VGND VGND VPWR VPWR _5611_/A sky130_fd_sc_hd__dlygate4sd3_1
XFILLER_103_556 VGND VGND VPWR VPWR sky130_fd_sc_hd__decap_3
XFILLER_103_567 VGND VGND VPWR VPWR sky130_fd_sc_hd__decap_3
XFILLER_88_256 VGND VGND VPWR VPWR sky130_fd_sc_hd__decap_3
XFILLER_95_29 VGND VGND VPWR VPWR sky130_fd_sc_hd__decap_3
X_6268_ _6364_/A VGND VGND VPWR VPWR _6268_/Y sky130_fd_sc_hd__inv_2
XFILLER_88_278 VGND VGND VPWR VPWR sky130_fd_sc_hd__decap_3
X_5219_ _5219_/A _5225_/B VGND VGND VPWR VPWR _7219_/D sky130_fd_sc_hd__and2_2
XFILLER_29_334 VGND VGND VPWR VPWR sky130_fd_sc_hd__fill_2
XFILLER_57_632 VGND VGND VPWR VPWR sky130_fd_sc_hd__decap_3
XFILLER_17_529 VGND VGND VPWR VPWR sky130_fd_sc_hd__decap_3
XFILLER_28_78 VGND VGND VPWR VPWR sky130_fd_sc_hd__decap_3
XFILLER_57_665 VGND VGND VPWR VPWR sky130_fd_sc_hd__decap_3
XFILLER_57_676 VGND VGND VPWR VPWR sky130_fd_sc_hd__decap_3
XFILLER_72_613 VGND VGND VPWR VPWR sky130_fd_sc_hd__decap_3
XFILLER_84_473 VGND VGND VPWR VPWR sky130_fd_sc_hd__decap_3
XFILLER_44_315 VGND VGND VPWR VPWR sky130_fd_sc_hd__fill_1
XFILLER_56_197 VGND VGND VPWR VPWR sky130_fd_sc_hd__decap_3
XFILLER_72_657 VGND VGND VPWR VPWR sky130_fd_sc_hd__decap_3
XFILLER_25_551 VGND VGND VPWR VPWR sky130_fd_sc_hd__decap_3
XFILLER_71_134 VGND VGND VPWR VPWR sky130_fd_sc_hd__decap_3
XFILLER_25_573 VGND VGND VPWR VPWR sky130_fd_sc_hd__decap_3
XFILLER_71_178 VGND VGND VPWR VPWR sky130_fd_sc_hd__decap_3
XFILLER_71_189 VGND VGND VPWR VPWR sky130_fd_sc_hd__decap_3
XTAP_TAPCELL_ROW_27_579 VGND VPWR sky130_fd_sc_hd__tapvpwrvgnd_1
XFILLER_12_245 VGND VGND VPWR VPWR sky130_fd_sc_hd__decap_3
XFILLER_80_690 VGND VGND VPWR VPWR sky130_fd_sc_hd__fill_1
XFILLER_100_50 VGND VGND VPWR VPWR sky130_fd_sc_hd__decap_3
XFILLER_40_587 VGND VGND VPWR VPWR sky130_fd_sc_hd__fill_1
XFILLER_40_598 VGND VGND VPWR VPWR sky130_fd_sc_hd__decap_3
XFILLER_60_32 VGND VGND VPWR VPWR sky130_fd_sc_hd__decap_3
XFILLER_60_65 VGND VGND VPWR VPWR sky130_fd_sc_hd__decap_3
XFILLER_60_98 VGND VGND VPWR VPWR sky130_fd_sc_hd__decap_3
XFILLER_113_309 VGND VGND VPWR VPWR sky130_fd_sc_hd__fill_1
XFILLER_4_466 VGND VGND VPWR VPWR sky130_fd_sc_hd__decap_3
XFILLER_4_477 VGND VGND VPWR VPWR sky130_fd_sc_hd__decap_3
XFILLER_106_361 VGND VGND VPWR VPWR sky130_fd_sc_hd__decap_3
XFILLER_79_201 VGND VGND VPWR VPWR sky130_fd_sc_hd__fill_1
XFILLER_79_212 VGND VGND VPWR VPWR sky130_fd_sc_hd__decap_3
XFILLER_67_407 VGND VGND VPWR VPWR sky130_fd_sc_hd__fill_2
XFILLER_79_234 VGND VGND VPWR VPWR sky130_fd_sc_hd__decap_3
XFILLER_79_256 VGND VGND VPWR VPWR sky130_fd_sc_hd__fill_2
XFILLER_48_610 VGND VGND VPWR VPWR sky130_fd_sc_hd__decap_3
XFILLER_79_278 VGND VGND VPWR VPWR sky130_fd_sc_hd__fill_2
XFILLER_48_643 VGND VGND VPWR VPWR sky130_fd_sc_hd__fill_1
XFILLER_48_654 VGND VGND VPWR VPWR sky130_fd_sc_hd__decap_3
XFILLER_85_40 VGND VGND VPWR VPWR sky130_fd_sc_hd__decap_3
XFILLER_94_237 VGND VGND VPWR VPWR sky130_fd_sc_hd__decap_3
XFILLER_94_259 VGND VGND VPWR VPWR sky130_fd_sc_hd__decap_3
XFILLER_48_687 VGND VGND VPWR VPWR sky130_fd_sc_hd__decap_3
XTAP_TAPCELL_ROW_46_800 VGND VPWR sky130_fd_sc_hd__tapvpwrvgnd_1
XFILLER_35_337 VGND VGND VPWR VPWR sky130_fd_sc_hd__decap_3
XFILLER_63_635 VGND VGND VPWR VPWR sky130_fd_sc_hd__decap_3
XFILLER_75_484 VGND VGND VPWR VPWR sky130_fd_sc_hd__decap_3
XFILLER_90_421 VGND VGND VPWR VPWR sky130_fd_sc_hd__fill_2
XFILLER_16_551 VGND VGND VPWR VPWR sky130_fd_sc_hd__decap_3
XFILLER_63_668 VGND VGND VPWR VPWR sky130_fd_sc_hd__decap_3
XFILLER_63_679 VGND VGND VPWR VPWR sky130_fd_sc_hd__decap_3
XFILLER_16_584 VGND VGND VPWR VPWR sky130_fd_sc_hd__decap_3
XFILLER_90_487 VGND VGND VPWR VPWR sky130_fd_sc_hd__fill_2
XFILLER_16_595 VGND VGND VPWR VPWR sky130_fd_sc_hd__decap_3
XFILLER_31_521 VGND VGND VPWR VPWR sky130_fd_sc_hd__decap_3
XFILLER_31_576 VGND VGND VPWR VPWR sky130_fd_sc_hd__decap_3
X_5570_ hold982/X _4927_/A _4929_/Y VGND VGND VPWR VPWR _7047_/D sky130_fd_sc_hd__o21a_2
XFILLER_116_103 VGND VGND VPWR VPWR sky130_fd_sc_hd__decap_3
XFILLER_116_125 VGND VGND VPWR VPWR sky130_fd_sc_hd__decap_3
XFILLER_7_271 VGND VGND VPWR VPWR sky130_fd_sc_hd__decap_3
X_7240_ _7365_/CLK _7240_/D _6520_/Y VGND VGND VPWR VPWR _7240_/Q sky130_fd_sc_hd__dfrtp_2
X_4452_ _4452_/A _4765_/B VGND VGND VPWR VPWR _4453_/A sky130_fd_sc_hd__or2_2
XFILLER_116_158 VGND VGND VPWR VPWR sky130_fd_sc_hd__fill_2
XFILLER_116_169 VGND VGND VPWR VPWR sky130_fd_sc_hd__decap_3
X_3403_ _3403_/A _4467_/B VGND VGND VPWR VPWR _4667_/B sky130_fd_sc_hd__or2_4
XPHY_EDGE_ROW_84_Left_201 VGND VGND VPWR VPWR sky130_fd_sc_hd__decap_3
X_7171_ _7368_/CLK _7171_/D _6451_/Y VGND VGND VPWR VPWR _7171_/Q sky130_fd_sc_hd__dfrtp_2
X_4383_ _4920_/A _4937_/A _4383_/C VGND VGND VPWR VPWR _4384_/C sky130_fd_sc_hd__and3_2
XFILLER_98_510 VGND VGND VPWR VPWR sky130_fd_sc_hd__decap_3
X_3334_ _3330_/Y _3528_/A _5156_/S VGND VGND VPWR VPWR _3334_/Y sky130_fd_sc_hd__o21ai_2
XFILLER_98_554 VGND VGND VPWR VPWR sky130_fd_sc_hd__decap_3
XFILLER_100_504 VGND VGND VPWR VPWR sky130_fd_sc_hd__decap_3
XFILLER_105_39 VGND VGND VPWR VPWR sky130_fd_sc_hd__decap_3
XFILLER_85_215 VGND VGND VPWR VPWR sky130_fd_sc_hd__fill_1
XFILLER_98_598 VGND VGND VPWR VPWR sky130_fd_sc_hd__decap_3
XFILLER_98_587 VGND VGND VPWR VPWR sky130_fd_sc_hd__fill_1
XFILLER_100_548 VGND VGND VPWR VPWR sky130_fd_sc_hd__decap_3
XFILLER_112_397 VGND VGND VPWR VPWR sky130_fd_sc_hd__decap_3
XFILLER_39_632 VGND VGND VPWR VPWR sky130_fd_sc_hd__decap_3
X_5004_ _5004_/A _5004_/B VGND VGND VPWR VPWR _5004_/X sky130_fd_sc_hd__or2_2
XFILLER_38_131 VGND VGND VPWR VPWR sky130_fd_sc_hd__fill_1
XFILLER_39_665 VGND VGND VPWR VPWR sky130_fd_sc_hd__decap_3
XFILLER_39_676 VGND VGND VPWR VPWR sky130_fd_sc_hd__decap_3
XFILLER_54_613 VGND VGND VPWR VPWR sky130_fd_sc_hd__decap_3
XFILLER_26_315 VGND VGND VPWR VPWR sky130_fd_sc_hd__decap_3
XFILLER_38_197 VGND VGND VPWR VPWR sky130_fd_sc_hd__fill_2
XFILLER_26_359 VGND VGND VPWR VPWR sky130_fd_sc_hd__decap_3
XFILLER_54_657 VGND VGND VPWR VPWR sky130_fd_sc_hd__decap_3
X_6955_ _6970_/CLK _6955_/D VGND VGND VPWR VPWR _6955_/Q sky130_fd_sc_hd__dfxtp_2
XPHY_EDGE_ROW_93_Left_210 VGND VGND VPWR VPWR sky130_fd_sc_hd__decap_3
XFILLER_41_318 VGND VGND VPWR VPWR sky130_fd_sc_hd__fill_2
XFILLER_53_178 VGND VGND VPWR VPWR sky130_fd_sc_hd__decap_3
XFILLER_62_690 VGND VGND VPWR VPWR sky130_fd_sc_hd__fill_1
X_6886_ _6943_/CLK _6886_/D VGND VGND VPWR VPWR _6886_/Q sky130_fd_sc_hd__dfxtp_2
XTAP_TAPCELL_ROW_24_538 VGND VPWR sky130_fd_sc_hd__tapvpwrvgnd_1
XFILLER_22_565 VGND VGND VPWR VPWR sky130_fd_sc_hd__decap_3
XFILLER_22_598 VGND VGND VPWR VPWR sky130_fd_sc_hd__decap_3
XFILLER_108_604 VGND VGND VPWR VPWR sky130_fd_sc_hd__decap_3
XFILLER_5_208 VGND VGND VPWR VPWR sky130_fd_sc_hd__decap_3
XFILLER_5_219 VGND VGND VPWR VPWR sky130_fd_sc_hd__decap_3
XFILLER_108_637 VGND VGND VPWR VPWR sky130_fd_sc_hd__decap_3
XFILLER_108_648 VGND VGND VPWR VPWR sky130_fd_sc_hd__decap_3
X_5699_ _7355_/Q hold984/X _5699_/S VGND VGND VPWR VPWR _6699_/D sky130_fd_sc_hd__mux2_2
XFILLER_107_158 VGND VGND VPWR VPWR sky130_fd_sc_hd__decap_3
XFILLER_89_532 VGND VGND VPWR VPWR sky130_fd_sc_hd__decap_3
X_7369_ _7405_/CLK _7369_/D _6649_/Y VGND VGND VPWR VPWR _7369_/Q sky130_fd_sc_hd__dfrtp_2
Xhold750 _6788_/Q VGND VGND VPWR VPWR _6788_/D sky130_fd_sc_hd__dlygate4sd3_1
Xhold761 _6950_/Q VGND VGND VPWR VPWR _6950_/D sky130_fd_sc_hd__dlygate4sd3_1
Xhold772 _6908_/Q VGND VGND VPWR VPWR _6908_/D sky130_fd_sc_hd__dlygate4sd3_1
XTAP_TAPCELL_ROW_73_1131 VGND VPWR sky130_fd_sc_hd__tapvpwrvgnd_1
Xhold783 _6906_/Q VGND VGND VPWR VPWR _6906_/D sky130_fd_sc_hd__dlygate4sd3_1
Xhold794 _6743_/Q VGND VGND VPWR VPWR _6743_/D sky130_fd_sc_hd__dlygate4sd3_1
XFILLER_103_375 VGND VGND VPWR VPWR sky130_fd_sc_hd__decap_3
XFILLER_1_469 VGND VGND VPWR VPWR sky130_fd_sc_hd__decap_3
XFILLER_89_576 VGND VGND VPWR VPWR sky130_fd_sc_hd__decap_3
XFILLER_76_248 VGND VGND VPWR VPWR sky130_fd_sc_hd__decap_3
XFILLER_17_304 VGND VGND VPWR VPWR sky130_fd_sc_hd__decap_3
XFILLER_57_462 VGND VGND VPWR VPWR sky130_fd_sc_hd__decap_3
XFILLER_17_337 VGND VGND VPWR VPWR sky130_fd_sc_hd__decap_3
XFILLER_29_164 VGND VGND VPWR VPWR sky130_fd_sc_hd__decap_3
XFILLER_45_635 VGND VGND VPWR VPWR sky130_fd_sc_hd__decap_3
XFILLER_72_421 VGND VGND VPWR VPWR sky130_fd_sc_hd__fill_1
XTAP_TAPCELL_ROW_4_296 VGND VPWR sky130_fd_sc_hd__tapvpwrvgnd_1
XFILLER_45_668 VGND VGND VPWR VPWR sky130_fd_sc_hd__decap_3
XFILLER_45_679 VGND VGND VPWR VPWR sky130_fd_sc_hd__decap_3
XFILLER_32_307 VGND VGND VPWR VPWR sky130_fd_sc_hd__fill_1
XFILLER_60_616 VGND VGND VPWR VPWR sky130_fd_sc_hd__decap_3
XTAP_TAPCELL_ROW_84_1260 VGND VPWR sky130_fd_sc_hd__tapvpwrvgnd_1
XPHY_EDGE_ROW_105_Right_105 VGND VGND VPWR VPWR sky130_fd_sc_hd__decap_3
XFILLER_111_60 VGND VGND VPWR VPWR sky130_fd_sc_hd__decap_3
XFILLER_13_543 VGND VGND VPWR VPWR sky130_fd_sc_hd__decap_3
XFILLER_13_576 VGND VGND VPWR VPWR sky130_fd_sc_hd__decap_3
XFILLER_9_514 VGND VGND VPWR VPWR sky130_fd_sc_hd__decap_3
XFILLER_9_503 VGND VGND VPWR VPWR sky130_fd_sc_hd__fill_1
XFILLER_40_384 VGND VGND VPWR VPWR sky130_fd_sc_hd__decap_3
XFILLER_71_75 VGND VGND VPWR VPWR sky130_fd_sc_hd__decap_3
XFILLER_9_547 VGND VGND VPWR VPWR sky130_fd_sc_hd__decap_3
XFILLER_65_9 VGND VGND VPWR VPWR sky130_fd_sc_hd__decap_3
XFILLER_114_607 VGND VGND VPWR VPWR sky130_fd_sc_hd__decap_3
XFILLER_99_307 VGND VGND VPWR VPWR sky130_fd_sc_hd__fill_1
XFILLER_113_117 VGND VGND VPWR VPWR sky130_fd_sc_hd__fill_1
XFILLER_4_285 VGND VGND VPWR VPWR sky130_fd_sc_hd__decap_3
XFILLER_106_180 VGND VGND VPWR VPWR sky130_fd_sc_hd__fill_1
XFILLER_0_480 VGND VGND VPWR VPWR sky130_fd_sc_hd__decap_3
XFILLER_95_535 VGND VGND VPWR VPWR sky130_fd_sc_hd__decap_3
XFILLER_48_440 VGND VGND VPWR VPWR sky130_fd_sc_hd__decap_3
XFILLER_67_259 VGND VGND VPWR VPWR sky130_fd_sc_hd__fill_1
XFILLER_95_579 VGND VGND VPWR VPWR sky130_fd_sc_hd__decap_3
XFILLER_36_613 VGND VGND VPWR VPWR sky130_fd_sc_hd__decap_3
XFILLER_75_281 VGND VGND VPWR VPWR sky130_fd_sc_hd__decap_3
XFILLER_36_657 VGND VGND VPWR VPWR sky130_fd_sc_hd__decap_3
Xplace410 _3380_/Y VGND VGND VPWR VPWR _4437_/B1 sky130_fd_sc_hd__buf_2
Xplace421 _3958_/S VGND VGND VPWR VPWR _4390_/B1 sky130_fd_sc_hd__buf_2
XFILLER_35_167 VGND VGND VPWR VPWR sky130_fd_sc_hd__fill_1
XFILLER_35_178 VGND VGND VPWR VPWR sky130_fd_sc_hd__decap_3
XFILLER_51_638 VGND VGND VPWR VPWR sky130_fd_sc_hd__decap_3
Xplace432 _3366_/X VGND VGND VPWR VPWR _4318_/B1 sky130_fd_sc_hd__buf_2
Xplace443 _4414_/A2 VGND VGND VPWR VPWR _4433_/B sky130_fd_sc_hd__buf_2
Xplace454 _6980_/Q VGND VGND VPWR VPWR _3313_/B sky130_fd_sc_hd__buf_2
X_6740_ _7378_/CLK _6740_/D VGND VGND VPWR VPWR _6740_/Q sky130_fd_sc_hd__dfxtp_2
XFILLER_44_690 VGND VGND VPWR VPWR sky130_fd_sc_hd__fill_1
X_3952_ _7364_/Q _4495_/A0 _3964_/S VGND VGND VPWR VPWR _7364_/D sky130_fd_sc_hd__mux2_2
XFILLER_31_340 VGND VGND VPWR VPWR sky130_fd_sc_hd__decap_3
XFILLER_31_362 VGND VGND VPWR VPWR sky130_fd_sc_hd__decap_3
X_6671_ _6672_/A VGND VGND VPWR VPWR _6671_/Y sky130_fd_sc_hd__inv_2
X_3883_ _6814_/Q _3889_/A2 _3883_/B1 _6819_/Q VGND VGND VPWR VPWR _3883_/X sky130_fd_sc_hd__a22o_2
XTAP_TAPCELL_ROW_21_508 VGND VPWR sky130_fd_sc_hd__tapvpwrvgnd_1
X_5622_ _5622_/A _5622_/B VGND VGND VPWR VPWR _7017_/D sky130_fd_sc_hd__nor2_2
XTAP_TAPCELL_ROW_98_1429 VGND VPWR sky130_fd_sc_hd__tapvpwrvgnd_1
XFILLER_104_128 VGND VGND VPWR VPWR sky130_fd_sc_hd__decap_3
XFILLER_105_629 VGND VGND VPWR VPWR sky130_fd_sc_hd__decap_3
X_7223_ _7351_/CLK _7223_/D _6503_/Y VGND VGND VPWR VPWR _7223_/Q sky130_fd_sc_hd__dfrtp_2
X_4435_ _7207_/Q _3945_/S _4394_/B _7367_/Q VGND VGND VPWR VPWR _4435_/X sky130_fd_sc_hd__a22o_2
XFILLER_116_27 VGND VGND VPWR VPWR sky130_fd_sc_hd__fill_1
X_7154_ _7355_/CLK _7154_/D _6434_/Y VGND VGND VPWR VPWR _7154_/Q sky130_fd_sc_hd__dfrtp_2
X_4366_ _4460_/A _4364_/Y _4313_/D _4315_/Y _4365_/X VGND VGND VPWR VPWR _4366_/X
+ sky130_fd_sc_hd__a32o_2
XFILLER_113_662 VGND VGND VPWR VPWR sky130_fd_sc_hd__decap_3
XFILLER_113_673 VGND VGND VPWR VPWR sky130_fd_sc_hd__decap_3
XFILLER_86_524 VGND VGND VPWR VPWR sky130_fd_sc_hd__decap_3
XFILLER_100_312 VGND VGND VPWR VPWR sky130_fd_sc_hd__decap_3
XFILLER_112_172 VGND VGND VPWR VPWR sky130_fd_sc_hd__decap_3
XFILLER_86_557 VGND VGND VPWR VPWR sky130_fd_sc_hd__decap_3
X_7085_ _7403_/CLK _7085_/D _6365_/Y VGND VGND VPWR VPWR _7085_/Q sky130_fd_sc_hd__dfrtp_2
X_4297_ _5113_/A _4297_/B VGND VGND VPWR VPWR _4297_/Y sky130_fd_sc_hd__nor2_2
XFILLER_98_395 VGND VGND VPWR VPWR sky130_fd_sc_hd__decap_3
XFILLER_100_378 VGND VGND VPWR VPWR sky130_fd_sc_hd__fill_1
XFILLER_39_440 VGND VGND VPWR VPWR sky130_fd_sc_hd__fill_1
XFILLER_39_462 VGND VGND VPWR VPWR sky130_fd_sc_hd__decap_3
XFILLER_27_635 VGND VGND VPWR VPWR sky130_fd_sc_hd__decap_3
XFILLER_73_218 VGND VGND VPWR VPWR sky130_fd_sc_hd__decap_3
XTAP_TAPCELL_ROW_57_939 VGND VPWR sky130_fd_sc_hd__tapvpwrvgnd_1
XFILLER_26_123 VGND VGND VPWR VPWR sky130_fd_sc_hd__decap_3
XFILLER_27_668 VGND VGND VPWR VPWR sky130_fd_sc_hd__decap_3
XFILLER_27_679 VGND VGND VPWR VPWR sky130_fd_sc_hd__decap_3
XFILLER_81_240 VGND VGND VPWR VPWR sky130_fd_sc_hd__decap_3
XTAP_TAPCELL_ROW_1_266 VGND VPWR sky130_fd_sc_hd__tapvpwrvgnd_1
XTAP_TAPCELL_ROW_107_1536 VGND VPWR sky130_fd_sc_hd__tapvpwrvgnd_1
XFILLER_14_307 VGND VGND VPWR VPWR sky130_fd_sc_hd__fill_1
XFILLER_26_156 VGND VGND VPWR VPWR sky130_fd_sc_hd__decap_3
XFILLER_26_189 VGND VGND VPWR VPWR sky130_fd_sc_hd__decap_3
XFILLER_42_616 VGND VGND VPWR VPWR sky130_fd_sc_hd__decap_3
XFILLER_25_57 VGND VGND VPWR VPWR sky130_fd_sc_hd__decap_3
X_6938_ _6941_/CLK _6938_/D VGND VGND VPWR VPWR _6938_/Q sky130_fd_sc_hd__dfxtp_2
XTAP_TAPCELL_ROW_37_696 VGND VPWR sky130_fd_sc_hd__tapvpwrvgnd_1
XFILLER_50_660 VGND VGND VPWR VPWR sky130_fd_sc_hd__decap_3
X_6869_ _6954_/CLK _6869_/D VGND VGND VPWR VPWR _6869_/Q sky130_fd_sc_hd__dfxtp_2
XFILLER_22_384 VGND VGND VPWR VPWR sky130_fd_sc_hd__fill_2
XFILLER_10_557 VGND VGND VPWR VPWR sky130_fd_sc_hd__decap_3
XFILLER_6_528 VGND VGND VPWR VPWR sky130_fd_sc_hd__decap_3
XFILLER_6_539 VGND VGND VPWR VPWR sky130_fd_sc_hd__decap_3
XFILLER_108_445 VGND VGND VPWR VPWR sky130_fd_sc_hd__decap_3
XFILLER_108_489 VGND VGND VPWR VPWR sky130_fd_sc_hd__decap_3
XFILLER_104_640 VGND VGND VPWR VPWR sky130_fd_sc_hd__decap_3
XFILLER_104_651 VGND VGND VPWR VPWR sky130_fd_sc_hd__decap_3
XFILLER_1_222 VGND VGND VPWR VPWR sky130_fd_sc_hd__fill_2
XTAP_TAPCELL_ROW_9_355 VGND VPWR sky130_fd_sc_hd__tapvpwrvgnd_1
XFILLER_104_684 VGND VGND VPWR VPWR sky130_fd_sc_hd__decap_3
XFILLER_1_266 VGND VGND VPWR VPWR sky130_fd_sc_hd__fill_2
XFILLER_89_362 VGND VGND VPWR VPWR sky130_fd_sc_hd__decap_3
Xhold591 _6751_/Q VGND VGND VPWR VPWR _6751_/D sky130_fd_sc_hd__dlygate4sd3_1
XFILLER_103_172 VGND VGND VPWR VPWR sky130_fd_sc_hd__decap_3
XFILLER_1_299 VGND VGND VPWR VPWR sky130_fd_sc_hd__decap_3
XFILLER_49_215 VGND VGND VPWR VPWR sky130_fd_sc_hd__decap_3
XFILLER_49_237 VGND VGND VPWR VPWR sky130_fd_sc_hd__fill_1
XFILLER_77_546 VGND VGND VPWR VPWR sky130_fd_sc_hd__decap_3
XFILLER_106_93 VGND VGND VPWR VPWR sky130_fd_sc_hd__decap_3
XFILLER_49_259 VGND VGND VPWR VPWR sky130_fd_sc_hd__decap_3
XFILLER_77_579 VGND VGND VPWR VPWR sky130_fd_sc_hd__decap_3
XFILLER_17_101 VGND VGND VPWR VPWR sky130_fd_sc_hd__decap_3
XFILLER_18_613 VGND VGND VPWR VPWR sky130_fd_sc_hd__decap_3
XFILLER_57_270 VGND VGND VPWR VPWR sky130_fd_sc_hd__fill_2
XFILLER_57_281 VGND VGND VPWR VPWR sky130_fd_sc_hd__fill_2
XFILLER_18_657 VGND VGND VPWR VPWR sky130_fd_sc_hd__decap_3
XFILLER_45_432 VGND VGND VPWR VPWR sky130_fd_sc_hd__fill_1
XFILLER_72_251 VGND VGND VPWR VPWR sky130_fd_sc_hd__fill_1
XFILLER_72_262 VGND VGND VPWR VPWR sky130_fd_sc_hd__decap_3
XFILLER_26_690 VGND VGND VPWR VPWR sky130_fd_sc_hd__fill_1
XFILLER_33_638 VGND VGND VPWR VPWR sky130_fd_sc_hd__decap_3
XFILLER_60_424 VGND VGND VPWR VPWR sky130_fd_sc_hd__decap_3
XFILLER_82_74 VGND VGND VPWR VPWR sky130_fd_sc_hd__fill_1
XFILLER_13_340 VGND VGND VPWR VPWR sky130_fd_sc_hd__fill_1
XFILLER_82_85 VGND VGND VPWR VPWR sky130_fd_sc_hd__decap_3
XFILLER_9_300 VGND VGND VPWR VPWR sky130_fd_sc_hd__fill_2
XFILLER_13_384 VGND VGND VPWR VPWR sky130_fd_sc_hd__decap_3
XFILLER_41_671 VGND VGND VPWR VPWR sky130_fd_sc_hd__fill_1
XFILLER_41_682 VGND VGND VPWR VPWR sky130_fd_sc_hd__decap_3
XFILLER_63_6 VGND VGND VPWR VPWR sky130_fd_sc_hd__decap_3
XFILLER_5_550 VGND VGND VPWR VPWR sky130_fd_sc_hd__decap_3
XFILLER_114_404 VGND VGND VPWR VPWR sky130_fd_sc_hd__decap_3
XFILLER_5_561 VGND VGND VPWR VPWR sky130_fd_sc_hd__decap_3
XFILLER_99_104 VGND VGND VPWR VPWR sky130_fd_sc_hd__decap_3
XFILLER_114_448 VGND VGND VPWR VPWR sky130_fd_sc_hd__decap_3
XFILLER_5_594 VGND VGND VPWR VPWR sky130_fd_sc_hd__decap_3
X_4220_ _7196_/Q _3964_/S _4346_/B1 _7388_/Q VGND VGND VPWR VPWR _4220_/X sky130_fd_sc_hd__a22o_2
XFILLER_110_610 VGND VGND VPWR VPWR sky130_fd_sc_hd__decap_3
XFILLER_110_643 VGND VGND VPWR VPWR sky130_fd_sc_hd__fill_1
X_4151_ _7019_/Q _4401_/A2 _4390_/B1 _7202_/Q _4150_/X VGND VGND VPWR VPWR _4151_/X
+ sky130_fd_sc_hd__a221o_2
XFILLER_110_654 VGND VGND VPWR VPWR sky130_fd_sc_hd__decap_3
XFILLER_68_568 VGND VGND VPWR VPWR sky130_fd_sc_hd__decap_3
XFILLER_83_505 VGND VGND VPWR VPWR sky130_fd_sc_hd__fill_1
XFILLER_83_516 VGND VGND VPWR VPWR sky130_fd_sc_hd__fill_1
XFILLER_95_365 VGND VGND VPWR VPWR sky130_fd_sc_hd__decap_3
X_4082_ _4082_/A _4068_/A VGND VGND VPWR VPWR _4082_/X sky130_fd_sc_hd__or2b_2
XFILLER_110_687 VGND VGND VPWR VPWR sky130_fd_sc_hd__decap_3
XFILLER_36_410 VGND VGND VPWR VPWR sky130_fd_sc_hd__decap_3
XFILLER_83_538 VGND VGND VPWR VPWR sky130_fd_sc_hd__decap_3
XFILLER_36_421 VGND VGND VPWR VPWR sky130_fd_sc_hd__fill_1
XFILLER_48_281 VGND VGND VPWR VPWR sky130_fd_sc_hd__decap_3
XFILLER_102_29 VGND VGND VPWR VPWR sky130_fd_sc_hd__fill_2
XFILLER_24_616 VGND VGND VPWR VPWR sky130_fd_sc_hd__decap_3
XFILLER_36_465 VGND VGND VPWR VPWR sky130_fd_sc_hd__decap_3
XFILLER_63_240 VGND VGND VPWR VPWR sky130_fd_sc_hd__decap_3
XFILLER_63_273 VGND VGND VPWR VPWR sky130_fd_sc_hd__fill_2
XFILLER_91_582 VGND VGND VPWR VPWR sky130_fd_sc_hd__decap_3
XFILLER_51_424 VGND VGND VPWR VPWR sky130_fd_sc_hd__decap_3
XFILLER_51_446 VGND VGND VPWR VPWR sky130_fd_sc_hd__fill_2
XFILLER_63_284 VGND VGND VPWR VPWR sky130_fd_sc_hd__decap_3
Xplace273 _3883_/B1 VGND VGND VPWR VPWR _3902_/B1 sky130_fd_sc_hd__buf_2
X_4984_ _5099_/A _4619_/Y _4624_/A VGND VGND VPWR VPWR _5031_/B sky130_fd_sc_hd__a21o_2
XFILLER_32_660 VGND VGND VPWR VPWR sky130_fd_sc_hd__decap_3
Xplace295 _3891_/A2 VGND VGND VPWR VPWR _3886_/B1 sky130_fd_sc_hd__buf_2
Xplace284 _3879_/A2 VGND VGND VPWR VPWR _3921_/A2 sky130_fd_sc_hd__buf_2
X_6723_ _6978_/CLK _6723_/D VGND VGND VPWR VPWR _6723_/Q sky130_fd_sc_hd__dfxtp_2
X_3935_ _7372_/Q _4478_/A0 _3947_/S VGND VGND VPWR VPWR _7372_/D sky130_fd_sc_hd__mux2_2
XTAP_TAPCELL_ROW_34_655 VGND VPWR sky130_fd_sc_hd__tapvpwrvgnd_1
X_6654_ _6654_/A VGND VGND VPWR VPWR _6654_/Y sky130_fd_sc_hd__inv_2
XTAP_TAPCELL_ROW_62_997 VGND VPWR sky130_fd_sc_hd__tapvpwrvgnd_1
XTAP_TAPCELL_ROW_102_1477 VGND VPWR sky130_fd_sc_hd__tapvpwrvgnd_1
X_5605_ _5605_/A _5622_/B VGND VGND VPWR VPWR _7025_/D sky130_fd_sc_hd__or2_2
X_3866_ _6696_/Q _6786_/Q _6874_/Q _6922_/Q _3991_/B _3665_/B VGND VGND VPWR VPWR
+ _3866_/X sky130_fd_sc_hd__mux4_2
XPHY_EDGE_ROW_12_Left_129 VGND VGND VPWR VPWR sky130_fd_sc_hd__decap_3
X_6585_ _6620_/A VGND VGND VPWR VPWR _6585_/Y sky130_fd_sc_hd__inv_2
X_3797_ _6750_/Q _3892_/A2 _3878_/A2 _6732_/Q VGND VGND VPWR VPWR _3797_/X sky130_fd_sc_hd__a22o_2
XFILLER_105_459 VGND VGND VPWR VPWR sky130_fd_sc_hd__decap_3
X_7206_ _7395_/CLK _7206_/D _6486_/Y VGND VGND VPWR VPWR _7206_/Q sky130_fd_sc_hd__dfrtp_2
X_4418_ _7023_/Q _4422_/A2 _4417_/X VGND VGND VPWR VPWR _4425_/C sky130_fd_sc_hd__a21o_2
X_5398_ _5398_/A0 _4997_/X _5409_/S VGND VGND VPWR VPWR _7134_/D sky130_fd_sc_hd__mux2_2
XTAP_TAPCELL_ROW_6_325 VGND VPWR sky130_fd_sc_hd__tapvpwrvgnd_1
XFILLER_99_682 VGND VGND VPWR VPWR sky130_fd_sc_hd__decap_3
XFILLER_99_671 VGND VGND VPWR VPWR sky130_fd_sc_hd__fill_1
XFILLER_101_632 VGND VGND VPWR VPWR sky130_fd_sc_hd__decap_3
XFILLER_113_470 VGND VGND VPWR VPWR sky130_fd_sc_hd__decap_3
X_7137_ _7332_/CLK _7137_/D _6417_/Y VGND VGND VPWR VPWR _7137_/Q sky130_fd_sc_hd__dfrtp_2
X_4349_ _7257_/Q _4356_/A2 _4349_/B1 _7225_/Q _4348_/X VGND VGND VPWR VPWR _4367_/A
+ sky130_fd_sc_hd__a221o_2
XFILLER_100_120 VGND VGND VPWR VPWR sky130_fd_sc_hd__decap_3
XFILLER_101_665 VGND VGND VPWR VPWR sky130_fd_sc_hd__decap_3
XFILLER_101_676 VGND VGND VPWR VPWR sky130_fd_sc_hd__decap_3
XFILLER_59_579 VGND VGND VPWR VPWR sky130_fd_sc_hd__decap_3
X_7068_ _7392_/CLK _7068_/D _6348_/Y VGND VGND VPWR VPWR _7068_/Q sky130_fd_sc_hd__dfrtp_2
XPHY_EDGE_ROW_21_Left_138 VGND VGND VPWR VPWR sky130_fd_sc_hd__decap_3
XFILLER_100_175 VGND VGND VPWR VPWR sky130_fd_sc_hd__decap_3
XFILLER_74_516 VGND VGND VPWR VPWR sky130_fd_sc_hd__fill_2
XFILLER_14_104 VGND VGND VPWR VPWR sky130_fd_sc_hd__decap_3
XFILLER_54_240 VGND VGND VPWR VPWR sky130_fd_sc_hd__decap_3
XFILLER_82_560 VGND VGND VPWR VPWR sky130_fd_sc_hd__decap_3
XTAP_TAPCELL_ROW_68_1063 VGND VPWR sky130_fd_sc_hd__tapvpwrvgnd_1
XFILLER_15_638 VGND VGND VPWR VPWR sky130_fd_sc_hd__decap_3
XFILLER_14_159 VGND VGND VPWR VPWR sky130_fd_sc_hd__decap_3
XFILLER_30_619 VGND VGND VPWR VPWR sky130_fd_sc_hd__decap_3
XFILLER_52_11 VGND VGND VPWR VPWR sky130_fd_sc_hd__fill_1
XFILLER_23_671 VGND VGND VPWR VPWR sky130_fd_sc_hd__fill_1
XFILLER_23_682 VGND VGND VPWR VPWR sky130_fd_sc_hd__decap_3
XPHY_EDGE_ROW_30_Left_147 VGND VGND VPWR VPWR sky130_fd_sc_hd__decap_3
XFILLER_10_321 VGND VGND VPWR VPWR sky130_fd_sc_hd__decap_3
XFILLER_10_365 VGND VGND VPWR VPWR sky130_fd_sc_hd__decap_3
XFILLER_6_303 VGND VGND VPWR VPWR sky130_fd_sc_hd__decap_3
XFILLER_6_325 VGND VGND VPWR VPWR sky130_fd_sc_hd__decap_3
XFILLER_10_398 VGND VGND VPWR VPWR sky130_fd_sc_hd__decap_3
XFILLER_6_358 VGND VGND VPWR VPWR sky130_fd_sc_hd__decap_3
XFILLER_108_264 VGND VGND VPWR VPWR sky130_fd_sc_hd__decap_3
XFILLER_2_531 VGND VGND VPWR VPWR sky130_fd_sc_hd__fill_1
XFILLER_2_542 VGND VGND VPWR VPWR sky130_fd_sc_hd__decap_3
XFILLER_2_575 VGND VGND VPWR VPWR sky130_fd_sc_hd__decap_3
XFILLER_104_492 VGND VGND VPWR VPWR sky130_fd_sc_hd__decap_3
XFILLER_111_429 VGND VGND VPWR VPWR sky130_fd_sc_hd__decap_3
XFILLER_77_310 VGND VGND VPWR VPWR sky130_fd_sc_hd__fill_1
XFILLER_77_321 VGND VGND VPWR VPWR sky130_fd_sc_hd__decap_3
XFILLER_89_192 VGND VGND VPWR VPWR sky130_fd_sc_hd__decap_3
XFILLER_96_129 VGND VGND VPWR VPWR sky130_fd_sc_hd__decap_3
XFILLER_65_505 VGND VGND VPWR VPWR sky130_fd_sc_hd__decap_3
XFILLER_77_365 VGND VGND VPWR VPWR sky130_fd_sc_hd__decap_3
XFILLER_77_387 VGND VGND VPWR VPWR sky130_fd_sc_hd__decap_3
XFILLER_92_302 VGND VGND VPWR VPWR sky130_fd_sc_hd__decap_3
XFILLER_18_421 VGND VGND VPWR VPWR sky130_fd_sc_hd__decap_3
XFILLER_65_549 VGND VGND VPWR VPWR sky130_fd_sc_hd__decap_3
XFILLER_93_62 VGND VGND VPWR VPWR sky130_fd_sc_hd__fill_2
XFILLER_45_295 VGND VGND VPWR VPWR sky130_fd_sc_hd__decap_3
XFILLER_60_221 VGND VGND VPWR VPWR sky130_fd_sc_hd__decap_3
XFILLER_73_582 VGND VGND VPWR VPWR sky130_fd_sc_hd__decap_3
XFILLER_60_265 VGND VGND VPWR VPWR sky130_fd_sc_hd__decap_3
XFILLER_14_660 VGND VGND VPWR VPWR sky130_fd_sc_hd__decap_3
XFILLER_60_276 VGND VGND VPWR VPWR sky130_fd_sc_hd__decap_3
X_3720_ _6911_/Q _3888_/A2 _3888_/B1 _6903_/Q VGND VGND VPWR VPWR _3720_/X sky130_fd_sc_hd__a22o_2
XTAP_TAPCELL_ROW_31_625 VGND VPWR sky130_fd_sc_hd__tapvpwrvgnd_1
Xclkbuf_leaf_40_clk clkbuf_leaf_1_clk/A VGND VGND VPWR VPWR _6970_/CLK sky130_fd_sc_hd__clkbuf_16
XFILLER_9_130 VGND VGND VPWR VPWR sky130_fd_sc_hd__fill_1
X_3651_ _3665_/A _3665_/B VGND VGND VPWR VPWR _3651_/Y sky130_fd_sc_hd__nor2_2
XFILLER_61_3 VGND VGND VPWR VPWR sky130_fd_sc_hd__decap_3
X_6370_ _6571_/A VGND VGND VPWR VPWR _6370_/Y sky130_fd_sc_hd__inv_2
X_3582_ _7348_/Q _3449_/X _3407_/X _7124_/Q VGND VGND VPWR VPWR _3583_/C sky130_fd_sc_hd__a22o_2
XTAP_TAPCELL_ROW_11_382 VGND VPWR sky130_fd_sc_hd__tapvpwrvgnd_1
X_5321_ _5321_/A0 _4932_/X _5340_/S VGND VGND VPWR VPWR _7170_/D sky130_fd_sc_hd__mux2_2
XFILLER_88_619 VGND VGND VPWR VPWR sky130_fd_sc_hd__decap_3
X_4203_ _4203_/A _4203_/B _4203_/C VGND VGND VPWR VPWR _4203_/X sky130_fd_sc_hd__and3_2
XFILLER_110_451 VGND VGND VPWR VPWR sky130_fd_sc_hd__decap_3
XFILLER_3_60 VGND VGND VPWR VPWR sky130_fd_sc_hd__fill_2
XFILLER_68_354 VGND VGND VPWR VPWR sky130_fd_sc_hd__decap_3
XFILLER_96_663 VGND VGND VPWR VPWR sky130_fd_sc_hd__decap_3
X_4134_ _7020_/Q _4401_/A2 _4390_/B1 _7203_/Q _4133_/X VGND VGND VPWR VPWR _4134_/X
+ sky130_fd_sc_hd__a221o_2
XFILLER_113_17 VGND VGND VPWR VPWR sky130_fd_sc_hd__decap_3
XFILLER_28_218 VGND VGND VPWR VPWR sky130_fd_sc_hd__decap_3
XTAP_TAPCELL_ROW_39_725 VGND VPWR sky130_fd_sc_hd__tapvpwrvgnd_1
XTAP_TAPCELL_ROW_39_714 VGND VPWR sky130_fd_sc_hd__tapvpwrvgnd_1
XFILLER_110_495 VGND VGND VPWR VPWR sky130_fd_sc_hd__decap_3
XFILLER_83_346 VGND VGND VPWR VPWR sky130_fd_sc_hd__decap_3
X_4065_ _7052_/Q _4488_/S _4406_/A2 _7404_/Q _4064_/X VGND VGND VPWR VPWR _4065_/X
+ sky130_fd_sc_hd__a221o_2
XFILLER_36_251 VGND VGND VPWR VPWR sky130_fd_sc_hd__fill_1
XFILLER_64_560 VGND VGND VPWR VPWR sky130_fd_sc_hd__decap_3
XFILLER_91_390 VGND VGND VPWR VPWR sky130_fd_sc_hd__fill_2
XTAP_TAPCELL_ROW_19_482 VGND VPWR sky130_fd_sc_hd__tapvpwrvgnd_1
XFILLER_12_619 VGND VGND VPWR VPWR sky130_fd_sc_hd__decap_3
XFILLER_24_446 VGND VGND VPWR VPWR sky130_fd_sc_hd__decap_3
XFILLER_51_254 VGND VGND VPWR VPWR sky130_fd_sc_hd__decap_3
XFILLER_51_298 VGND VGND VPWR VPWR sky130_fd_sc_hd__decap_3
X_4967_ _4967_/A _4967_/B VGND VGND VPWR VPWR _4967_/X sky130_fd_sc_hd__or2_2
Xclkbuf_leaf_31_clk clkload2/A VGND VGND VPWR VPWR _7351_/CLK sky130_fd_sc_hd__clkbuf_16
X_6706_ _6965_/CLK _6706_/D VGND VGND VPWR VPWR _6706_/Q sky130_fd_sc_hd__dfxtp_2
X_4898_ _4799_/A _3756_/X _4897_/X _5010_/A VGND VGND VPWR VPWR _4898_/X sky130_fd_sc_hd__a211o_2
X_3918_ _6915_/Q _3918_/A2 _3918_/B1 _6779_/Q _3917_/X VGND VGND VPWR VPWR _3918_/X
+ sky130_fd_sc_hd__a221o_2
XFILLER_20_663 VGND VGND VPWR VPWR sky130_fd_sc_hd__decap_3
X_6637_ _6637_/A VGND VGND VPWR VPWR _6637_/Y sky130_fd_sc_hd__inv_2
X_3849_ _6859_/Q _3922_/A2 _3887_/B1 _6899_/Q _3848_/X VGND VGND VPWR VPWR _3849_/X
+ sky130_fd_sc_hd__a221o_2
X_6568_ _6571_/A VGND VGND VPWR VPWR _6568_/Y sky130_fd_sc_hd__inv_2
XFILLER_3_306 VGND VGND VPWR VPWR sky130_fd_sc_hd__decap_3
XTAP_TAPCELL_ROW_115_1635 VGND VPWR sky130_fd_sc_hd__tapvpwrvgnd_1
XFILLER_98_18 VGND VGND VPWR VPWR sky130_fd_sc_hd__fill_2
XFILLER_105_223 VGND VGND VPWR VPWR sky130_fd_sc_hd__fill_1
X_6499_ _6566_/A VGND VGND VPWR VPWR _6499_/Y sky130_fd_sc_hd__inv_2
XFILLER_105_278 VGND VGND VPWR VPWR sky130_fd_sc_hd__fill_2
Xoutput471 _5657_/B VGND VGND VPWR VPWR alu_result_out[20] sky130_fd_sc_hd__clkdlybuf4s25_1
Xoutput460 _5658_/A VGND VGND VPWR VPWR alu_result_out[10] sky130_fd_sc_hd__clkdlybuf4s25_1
XFILLER_59_321 VGND VGND VPWR VPWR sky130_fd_sc_hd__decap_3
Xoutput493 _5645_/X VGND VGND VPWR VPWR instruction_out[12] sky130_fd_sc_hd__clkdlybuf4s25_1
Xoutput482 _5655_/A VGND VGND VPWR VPWR alu_result_out[30] sky130_fd_sc_hd__clkdlybuf4s25_1
XFILLER_59_343 VGND VGND VPWR VPWR sky130_fd_sc_hd__decap_3
XFILLER_87_641 VGND VGND VPWR VPWR sky130_fd_sc_hd__decap_3
XFILLER_74_324 VGND VGND VPWR VPWR sky130_fd_sc_hd__decap_3
XFILLER_87_685 VGND VGND VPWR VPWR sky130_fd_sc_hd__decap_3
XFILLER_101_495 VGND VGND VPWR VPWR sky130_fd_sc_hd__decap_3
XFILLER_86_184 VGND VGND VPWR VPWR sky130_fd_sc_hd__decap_3
XFILLER_74_368 VGND VGND VPWR VPWR sky130_fd_sc_hd__fill_1
XFILLER_27_284 VGND VGND VPWR VPWR sky130_fd_sc_hd__decap_3
XFILLER_55_582 VGND VGND VPWR VPWR sky130_fd_sc_hd__decap_3
XFILLER_63_21 VGND VGND VPWR VPWR sky130_fd_sc_hd__decap_3
XFILLER_63_54 VGND VGND VPWR VPWR sky130_fd_sc_hd__fill_2
XFILLER_70_552 VGND VGND VPWR VPWR sky130_fd_sc_hd__decap_3
XFILLER_30_416 VGND VGND VPWR VPWR sky130_fd_sc_hd__fill_1
XFILLER_42_276 VGND VGND VPWR VPWR sky130_fd_sc_hd__fill_2
XFILLER_70_585 VGND VGND VPWR VPWR sky130_fd_sc_hd__decap_3
XFILLER_11_641 VGND VGND VPWR VPWR sky130_fd_sc_hd__decap_3
XFILLER_8_49 VGND VGND VPWR VPWR sky130_fd_sc_hd__fill_1
Xclkbuf_leaf_22_clk clkload5/A VGND VGND VPWR VPWR _7365_/CLK sky130_fd_sc_hd__clkbuf_16
XFILLER_11_685 VGND VGND VPWR VPWR sky130_fd_sc_hd__decap_3
XFILLER_7_612 VGND VGND VPWR VPWR sky130_fd_sc_hd__decap_3
XFILLER_7_623 VGND VGND VPWR VPWR sky130_fd_sc_hd__decap_3
XFILLER_7_656 VGND VGND VPWR VPWR sky130_fd_sc_hd__decap_3
XFILLER_109_573 VGND VGND VPWR VPWR sky130_fd_sc_hd__decap_3
XTAP_TAPCELL_ROW_90_1329 VGND VPWR sky130_fd_sc_hd__tapvpwrvgnd_1
XFILLER_2_361 VGND VGND VPWR VPWR sky130_fd_sc_hd__decap_3
XFILLER_78_663 VGND VGND VPWR VPWR sky130_fd_sc_hd__decap_3
XFILLER_93_600 VGND VGND VPWR VPWR sky130_fd_sc_hd__decap_3
XFILLER_65_346 VGND VGND VPWR VPWR sky130_fd_sc_hd__fill_1
XFILLER_77_195 VGND VGND VPWR VPWR sky130_fd_sc_hd__decap_3
XFILLER_92_110 VGND VGND VPWR VPWR sky130_fd_sc_hd__decap_3
XFILLER_93_644 VGND VGND VPWR VPWR sky130_fd_sc_hd__decap_3
XFILLER_80_305 VGND VGND VPWR VPWR sky130_fd_sc_hd__decap_3
XFILLER_93_688 VGND VGND VPWR VPWR sky130_fd_sc_hd__decap_3
XFILLER_33_221 VGND VGND VPWR VPWR sky130_fd_sc_hd__decap_3
XFILLER_46_582 VGND VGND VPWR VPWR sky130_fd_sc_hd__decap_3
XFILLER_33_243 VGND VGND VPWR VPWR sky130_fd_sc_hd__decap_3
X_4821_ _4799_/A _3704_/X _4819_/X _5010_/A VGND VGND VPWR VPWR _4821_/X sky130_fd_sc_hd__a211o_2
XTAP_TAPCELL_ROW_16_441 VGND VPWR sky130_fd_sc_hd__tapvpwrvgnd_1
XFILLER_33_276 VGND VGND VPWR VPWR sky130_fd_sc_hd__decap_3
XFILLER_33_287 VGND VGND VPWR VPWR sky130_fd_sc_hd__decap_3
XFILLER_61_585 VGND VGND VPWR VPWR sky130_fd_sc_hd__decap_3
XTAP_TAPCELL_ROW_44_783 VGND VPWR sky130_fd_sc_hd__tapvpwrvgnd_1
Xclkbuf_leaf_13_clk clkload3/A VGND VGND VPWR VPWR _7403_/CLK sky130_fd_sc_hd__clkbuf_16
X_4752_ _4997_/A1 _7006_/D _4751_/Y VGND VGND VPWR VPWR _4752_/X sky130_fd_sc_hd__a21o_2
X_4683_ _6997_/Q _6998_/Q _5633_/B VGND VGND VPWR VPWR _4683_/X sky130_fd_sc_hd__o21a_2
X_3703_ _6938_/Q _3768_/A2 _3918_/B1 _6802_/Q VGND VGND VPWR VPWR _3703_/X sky130_fd_sc_hd__a22o_2
X_6422_ _6654_/A VGND VGND VPWR VPWR _6422_/Y sky130_fd_sc_hd__inv_2
X_3634_ _3636_/B _3631_/Y _3632_/X _3633_/Y VGND VGND VPWR VPWR _3634_/Y sky130_fd_sc_hd__o211ai_4
XFILLER_115_532 VGND VGND VPWR VPWR sky130_fd_sc_hd__decap_3
X_6353_ _6685_/A VGND VGND VPWR VPWR _6353_/Y sky130_fd_sc_hd__inv_2
X_3565_ _3469_/A _3469_/B _3564_/X _3449_/A VGND VGND VPWR VPWR _5648_/B sky130_fd_sc_hd__o211a_2
XFILLER_0_309 VGND VGND VPWR VPWR sky130_fd_sc_hd__decap_3
XFILLER_115_576 VGND VGND VPWR VPWR sky130_fd_sc_hd__decap_3
X_6284_ _6462_/A VGND VGND VPWR VPWR _6284_/Y sky130_fd_sc_hd__inv_2
X_5304_ _5304_/A0 _4792_/X _5323_/S VGND VGND VPWR VPWR _7178_/D sky130_fd_sc_hd__mux2_2
X_3496_ _7215_/Q _4284_/A2 _5159_/S _7279_/Q _3495_/X VGND VGND VPWR VPWR _3496_/X
+ sky130_fd_sc_hd__a221o_2
XFILLER_88_427 VGND VGND VPWR VPWR sky130_fd_sc_hd__decap_3
XFILLER_69_641 VGND VGND VPWR VPWR sky130_fd_sc_hd__decap_3
XFILLER_68_162 VGND VGND VPWR VPWR sky130_fd_sc_hd__decap_3
XFILLER_69_685 VGND VGND VPWR VPWR sky130_fd_sc_hd__decap_3
XFILLER_84_622 VGND VGND VPWR VPWR sky130_fd_sc_hd__decap_3
XTAP_TAPCELL_ROW_110_1576 VGND VPWR sky130_fd_sc_hd__tapvpwrvgnd_1
XFILLER_110_292 VGND VGND VPWR VPWR sky130_fd_sc_hd__fill_1
XFILLER_56_324 VGND VGND VPWR VPWR sky130_fd_sc_hd__fill_1
XFILLER_56_335 VGND VGND VPWR VPWR sky130_fd_sc_hd__decap_3
XFILLER_68_195 VGND VGND VPWR VPWR sky130_fd_sc_hd__fill_1
X_5097_ _6985_/Q _5120_/A VGND VGND VPWR VPWR _5098_/B sky130_fd_sc_hd__nor2_2
X_4117_ _4205_/A _4117_/B _4117_/C VGND VGND VPWR VPWR _4117_/Y sky130_fd_sc_hd__nand3_2
XFILLER_44_519 VGND VGND VPWR VPWR sky130_fd_sc_hd__fill_1
XFILLER_56_368 VGND VGND VPWR VPWR sky130_fd_sc_hd__decap_3
XFILLER_71_316 VGND VGND VPWR VPWR sky130_fd_sc_hd__decap_3
XFILLER_84_666 VGND VGND VPWR VPWR sky130_fd_sc_hd__decap_3
X_4048_ _7117_/Q _4434_/A2 _4434_/B1 _7149_/Q VGND VGND VPWR VPWR _4048_/X sky130_fd_sc_hd__a22o_2
XFILLER_37_582 VGND VGND VPWR VPWR sky130_fd_sc_hd__decap_3
XFILLER_24_243 VGND VGND VPWR VPWR sky130_fd_sc_hd__decap_3
XTAP_TAPCELL_ROW_65_1033 VGND VPWR sky130_fd_sc_hd__tapvpwrvgnd_1
XFILLER_24_265 VGND VGND VPWR VPWR sky130_fd_sc_hd__decap_3
XFILLER_52_574 VGND VGND VPWR VPWR sky130_fd_sc_hd__decap_3
XFILLER_24_298 VGND VGND VPWR VPWR sky130_fd_sc_hd__decap_3
XPHY_EDGE_ROW_104_Left_221 VGND VGND VPWR VPWR sky130_fd_sc_hd__decap_3
XFILLER_4_604 VGND VGND VPWR VPWR sky130_fd_sc_hd__decap_3
XFILLER_106_510 VGND VGND VPWR VPWR sky130_fd_sc_hd__decap_3
XFILLER_3_103 VGND VGND VPWR VPWR sky130_fd_sc_hd__fill_1
XFILLER_4_637 VGND VGND VPWR VPWR sky130_fd_sc_hd__decap_3
XFILLER_4_648 VGND VGND VPWR VPWR sky130_fd_sc_hd__decap_3
XFILLER_106_554 VGND VGND VPWR VPWR sky130_fd_sc_hd__decap_3
XFILLER_3_169 VGND VGND VPWR VPWR sky130_fd_sc_hd__decap_3
XFILLER_79_405 VGND VGND VPWR VPWR sky130_fd_sc_hd__fill_2
XTAP_TAPCELL_ROW_76_1162 VGND VPWR sky130_fd_sc_hd__tapvpwrvgnd_1
XFILLER_106_587 VGND VGND VPWR VPWR sky130_fd_sc_hd__fill_1
XFILLER_106_598 VGND VGND VPWR VPWR sky130_fd_sc_hd__decap_3
XFILLER_58_65 VGND VGND VPWR VPWR sky130_fd_sc_hd__fill_2
XFILLER_94_408 VGND VGND VPWR VPWR sky130_fd_sc_hd__fill_2
XFILLER_47_302 VGND VGND VPWR VPWR sky130_fd_sc_hd__decap_3
XFILLER_75_600 VGND VGND VPWR VPWR sky130_fd_sc_hd__decap_3
XFILLER_94_419 VGND VGND VPWR VPWR sky130_fd_sc_hd__fill_1
XPHY_EDGE_ROW_113_Left_230 VGND VGND VPWR VPWR sky130_fd_sc_hd__decap_3
XFILLER_59_184 VGND VGND VPWR VPWR sky130_fd_sc_hd__decap_3
XFILLER_59_195 VGND VGND VPWR VPWR sky130_fd_sc_hd__decap_3
XFILLER_74_121 VGND VGND VPWR VPWR sky130_fd_sc_hd__decap_3
XFILLER_75_644 VGND VGND VPWR VPWR sky130_fd_sc_hd__decap_3
XFILLER_114_71 VGND VGND VPWR VPWR sky130_fd_sc_hd__decap_3
XFILLER_28_560 VGND VGND VPWR VPWR sky130_fd_sc_hd__decap_3
XFILLER_35_508 VGND VGND VPWR VPWR sky130_fd_sc_hd__decap_3
XFILLER_47_357 VGND VGND VPWR VPWR sky130_fd_sc_hd__decap_3
XFILLER_62_305 VGND VGND VPWR VPWR sky130_fd_sc_hd__decap_3
XFILLER_74_154 VGND VGND VPWR VPWR sky130_fd_sc_hd__decap_3
XFILLER_74_42 VGND VGND VPWR VPWR sky130_fd_sc_hd__decap_3
XFILLER_75_688 VGND VGND VPWR VPWR sky130_fd_sc_hd__decap_3
XFILLER_90_625 VGND VGND VPWR VPWR sky130_fd_sc_hd__decap_3
XFILLER_90_669 VGND VGND VPWR VPWR sky130_fd_sc_hd__decap_3
XTAP_TAPCELL_ROW_87_1291 VGND VPWR sky130_fd_sc_hd__tapvpwrvgnd_1
XFILLER_15_287 VGND VGND VPWR VPWR sky130_fd_sc_hd__decap_3
XFILLER_43_585 VGND VGND VPWR VPWR sky130_fd_sc_hd__decap_3
XFILLER_30_235 VGND VGND VPWR VPWR sky130_fd_sc_hd__decap_3
XFILLER_90_41 VGND VGND VPWR VPWR sky130_fd_sc_hd__decap_3
XTAP_TAPCELL_ROW_41_742 VGND VPWR sky130_fd_sc_hd__tapvpwrvgnd_1
XTAP_TAPCELL_ROW_13_411 VGND VPWR sky130_fd_sc_hd__tapvpwrvgnd_1
XFILLER_30_268 VGND VGND VPWR VPWR sky130_fd_sc_hd__decap_3
XFILLER_90_85 VGND VGND VPWR VPWR sky130_fd_sc_hd__fill_2
XFILLER_7_431 VGND VGND VPWR VPWR sky130_fd_sc_hd__fill_2
XFILLER_116_307 VGND VGND VPWR VPWR sky130_fd_sc_hd__fill_1
XFILLER_116_329 VGND VGND VPWR VPWR sky130_fd_sc_hd__fill_2
X_3350_ _5129_/B _3350_/B VGND VGND VPWR VPWR _3350_/Y sky130_fd_sc_hd__nor2_2
XFILLER_112_513 VGND VGND VPWR VPWR sky130_fd_sc_hd__decap_3
XFILLER_97_202 VGND VGND VPWR VPWR sky130_fd_sc_hd__fill_1
XFILLER_112_557 VGND VGND VPWR VPWR sky130_fd_sc_hd__decap_3
X_5020_ _5020_/A _5020_/B _4373_/Y VGND VGND VPWR VPWR _5020_/X sky130_fd_sc_hd__or3b_2
XFILLER_24_3 VGND VGND VPWR VPWR sky130_fd_sc_hd__fill_1
XFILLER_66_622 VGND VGND VPWR VPWR sky130_fd_sc_hd__decap_3
XFILLER_78_460 VGND VGND VPWR VPWR sky130_fd_sc_hd__fill_2
XFILLER_97_279 VGND VGND VPWR VPWR sky130_fd_sc_hd__fill_1
Xclkbuf_leaf_2_clk clkload0/A VGND VGND VPWR VPWR _6954_/CLK sky130_fd_sc_hd__clkbuf_16
Xhold1109 _7299_/Q VGND VGND VPWR VPWR _4563_/A sky130_fd_sc_hd__dlygate4sd3_1
XFILLER_38_324 VGND VGND VPWR VPWR sky130_fd_sc_hd__decap_3
XTAP_TAPCELL_ROW_49_842 VGND VPWR sky130_fd_sc_hd__tapvpwrvgnd_1
XFILLER_38_357 VGND VGND VPWR VPWR sky130_fd_sc_hd__decap_3
XFILLER_38_368 VGND VGND VPWR VPWR sky130_fd_sc_hd__decap_3
XFILLER_53_305 VGND VGND VPWR VPWR sky130_fd_sc_hd__decap_3
XFILLER_65_154 VGND VGND VPWR VPWR sky130_fd_sc_hd__decap_3
XFILLER_66_666 VGND VGND VPWR VPWR sky130_fd_sc_hd__decap_3
XFILLER_81_603 VGND VGND VPWR VPWR sky130_fd_sc_hd__decap_3
XFILLER_19_582 VGND VGND VPWR VPWR sky130_fd_sc_hd__decap_3
XFILLER_80_124 VGND VGND VPWR VPWR sky130_fd_sc_hd__decap_3
XFILLER_81_647 VGND VGND VPWR VPWR sky130_fd_sc_hd__decap_3
X_6971_ clkload6/A _6971_/D VGND VGND VPWR VPWR _6971_/Q sky130_fd_sc_hd__dfxtp_2
XFILLER_53_349 VGND VGND VPWR VPWR sky130_fd_sc_hd__fill_1
XFILLER_110_18 VGND VGND VPWR VPWR sky130_fd_sc_hd__decap_3
XFILLER_110_29 VGND VGND VPWR VPWR sky130_fd_sc_hd__decap_3
XFILLER_34_574 VGND VGND VPWR VPWR sky130_fd_sc_hd__decap_3
XFILLER_21_246 VGND VGND VPWR VPWR sky130_fd_sc_hd__decap_3
XFILLER_61_393 VGND VGND VPWR VPWR sky130_fd_sc_hd__fill_2
X_4804_ _4804_/A _4804_/B VGND VGND VPWR VPWR _4804_/X sky130_fd_sc_hd__or2_2
X_4735_ _4735_/A0 _4734_/X _4837_/S VGND VGND VPWR VPWR _7277_/D sky130_fd_sc_hd__mux2_2
XFILLER_9_81 VGND VGND VPWR VPWR sky130_fd_sc_hd__decap_3
X_4666_ _6997_/Q _4667_/B VGND VGND VPWR VPWR _4908_/A sky130_fd_sc_hd__xnor2_2
X_7385_ _7398_/CLK _7385_/D _6665_/Y VGND VGND VPWR VPWR _7385_/Q sky130_fd_sc_hd__dfrtp_2
Xhold910 _6718_/Q VGND VGND VPWR VPWR hold910/X sky130_fd_sc_hd__dlygate4sd3_1
Xhold921 _6715_/Q VGND VGND VPWR VPWR hold921/X sky130_fd_sc_hd__dlygate4sd3_1
X_6405_ _6596_/A VGND VGND VPWR VPWR _6405_/Y sky130_fd_sc_hd__inv_2
X_4597_ _7282_/Q _5140_/A0 _4599_/S VGND VGND VPWR VPWR _7282_/D sky130_fd_sc_hd__mux2_2
X_3617_ _4614_/C _3616_/B _3605_/Y VGND VGND VPWR VPWR _3617_/X sky130_fd_sc_hd__o21a_2
XFILLER_1_607 VGND VGND VPWR VPWR sky130_fd_sc_hd__decap_3
Xhold932 _7029_/Q VGND VGND VPWR VPWR hold932/X sky130_fd_sc_hd__dlygate4sd3_1
Xhold954 _6704_/Q VGND VGND VPWR VPWR hold954/X sky130_fd_sc_hd__dlygate4sd3_1
Xhold943 _7018_/Q VGND VGND VPWR VPWR _5619_/A sky130_fd_sc_hd__dlygate4sd3_1
X_6336_ _6629_/A VGND VGND VPWR VPWR _6336_/Y sky130_fd_sc_hd__inv_2
X_3548_ _3621_/A _4938_/A _3609_/B VGND VGND VPWR VPWR _3548_/X sky130_fd_sc_hd__or3_2
XFILLER_103_535 VGND VGND VPWR VPWR sky130_fd_sc_hd__decap_3
XFILLER_1_629 VGND VGND VPWR VPWR sky130_fd_sc_hd__decap_3
Xhold998 _7196_/Q VGND VGND VPWR VPWR hold998/X sky130_fd_sc_hd__dlygate4sd3_1
Xhold987 _6710_/Q VGND VGND VPWR VPWR hold987/X sky130_fd_sc_hd__dlygate4sd3_1
Xhold976 _7406_/Q VGND VGND VPWR VPWR hold976/X sky130_fd_sc_hd__dlygate4sd3_1
Xhold965 _7210_/Q VGND VGND VPWR VPWR hold965/X sky130_fd_sc_hd__dlygate4sd3_1
XFILLER_88_235 VGND VGND VPWR VPWR sky130_fd_sc_hd__decap_3
X_6267_ _6685_/A VGND VGND VPWR VPWR _6267_/Y sky130_fd_sc_hd__inv_2
X_3479_ _7152_/Q _4352_/B1 _3478_/X VGND VGND VPWR VPWR _3482_/A sky130_fd_sc_hd__a21o_2
XFILLER_103_579 VGND VGND VPWR VPWR sky130_fd_sc_hd__decap_3
XFILLER_29_302 VGND VGND VPWR VPWR sky130_fd_sc_hd__fill_1
XFILLER_57_600 VGND VGND VPWR VPWR sky130_fd_sc_hd__decap_3
XFILLER_69_460 VGND VGND VPWR VPWR sky130_fd_sc_hd__fill_1
XFILLER_28_57 VGND VGND VPWR VPWR sky130_fd_sc_hd__decap_3
XFILLER_29_346 VGND VGND VPWR VPWR sky130_fd_sc_hd__decap_3
XFILLER_57_644 VGND VGND VPWR VPWR sky130_fd_sc_hd__decap_3
X_5149_ _5145_/A _4852_/A _5147_/X _5148_/X VGND VGND VPWR VPWR _5149_/Y sky130_fd_sc_hd__o211ai_2
XFILLER_56_154 VGND VGND VPWR VPWR sky130_fd_sc_hd__fill_1
XFILLER_57_688 VGND VGND VPWR VPWR sky130_fd_sc_hd__decap_3
XFILLER_56_176 VGND VGND VPWR VPWR sky130_fd_sc_hd__decap_3
XFILLER_71_113 VGND VGND VPWR VPWR sky130_fd_sc_hd__decap_3
XFILLER_72_625 VGND VGND VPWR VPWR sky130_fd_sc_hd__decap_3
XFILLER_44_349 VGND VGND VPWR VPWR sky130_fd_sc_hd__decap_3
XFILLER_71_146 VGND VGND VPWR VPWR sky130_fd_sc_hd__decap_3
XFILLER_72_669 VGND VGND VPWR VPWR sky130_fd_sc_hd__decap_3
XFILLER_25_585 VGND VGND VPWR VPWR sky130_fd_sc_hd__decap_3
XFILLER_12_213 VGND VGND VPWR VPWR sky130_fd_sc_hd__decap_3
XFILLER_40_522 VGND VGND VPWR VPWR sky130_fd_sc_hd__fill_1
XFILLER_40_533 VGND VGND VPWR VPWR sky130_fd_sc_hd__decap_3
XFILLER_44_89 VGND VGND VPWR VPWR sky130_fd_sc_hd__fill_1
XFILLER_12_268 VGND VGND VPWR VPWR sky130_fd_sc_hd__fill_2
XFILLER_40_566 VGND VGND VPWR VPWR sky130_fd_sc_hd__decap_3
XFILLER_8_217 VGND VGND VPWR VPWR sky130_fd_sc_hd__decap_3
XFILLER_60_55 VGND VGND VPWR VPWR sky130_fd_sc_hd__fill_1
XFILLER_8_239 VGND VGND VPWR VPWR sky130_fd_sc_hd__decap_3
XFILLER_20_290 VGND VGND VPWR VPWR sky130_fd_sc_hd__decap_3
XFILLER_60_88 VGND VGND VPWR VPWR sky130_fd_sc_hd__fill_1
XFILLER_109_71 VGND VGND VPWR VPWR sky130_fd_sc_hd__decap_3
XFILLER_4_489 VGND VGND VPWR VPWR sky130_fd_sc_hd__decap_3
XFILLER_0_640 VGND VGND VPWR VPWR sky130_fd_sc_hd__decap_3
XFILLER_106_395 VGND VGND VPWR VPWR sky130_fd_sc_hd__decap_3
XFILLER_69_97 VGND VGND VPWR VPWR sky130_fd_sc_hd__fill_1
XFILLER_0_651 VGND VGND VPWR VPWR sky130_fd_sc_hd__decap_3
XFILLER_0_673 VGND VGND VPWR VPWR sky130_fd_sc_hd__decap_3
XFILLER_94_205 VGND VGND VPWR VPWR sky130_fd_sc_hd__decap_3
XFILLER_48_622 VGND VGND VPWR VPWR sky130_fd_sc_hd__decap_3
XFILLER_75_430 VGND VGND VPWR VPWR sky130_fd_sc_hd__decap_3
XTAP_TAPCELL_ROW_89_1320 VGND VPWR sky130_fd_sc_hd__tapvpwrvgnd_1
XFILLER_47_154 VGND VGND VPWR VPWR sky130_fd_sc_hd__decap_3
XFILLER_48_666 VGND VGND VPWR VPWR sky130_fd_sc_hd__decap_3
XFILLER_63_603 VGND VGND VPWR VPWR sky130_fd_sc_hd__decap_3
XFILLER_75_463 VGND VGND VPWR VPWR sky130_fd_sc_hd__fill_2
XTAP_TAPCELL_ROW_46_801 VGND VPWR sky130_fd_sc_hd__tapvpwrvgnd_1
XFILLER_35_327 VGND VGND VPWR VPWR sky130_fd_sc_hd__decap_3
XFILLER_62_102 VGND VGND VPWR VPWR sky130_fd_sc_hd__decap_3
XFILLER_63_647 VGND VGND VPWR VPWR sky130_fd_sc_hd__decap_3
XFILLER_75_474 VGND VGND VPWR VPWR sky130_fd_sc_hd__decap_3
XFILLER_35_349 VGND VGND VPWR VPWR sky130_fd_sc_hd__decap_3
XFILLER_16_563 VGND VGND VPWR VPWR sky130_fd_sc_hd__decap_3
XFILLER_90_477 VGND VGND VPWR VPWR sky130_fd_sc_hd__decap_3
XFILLER_43_393 VGND VGND VPWR VPWR sky130_fd_sc_hd__decap_3
XFILLER_93_6 VGND VGND VPWR VPWR sky130_fd_sc_hd__decap_3
XFILLER_31_588 VGND VGND VPWR VPWR sky130_fd_sc_hd__decap_3
X_4520_ _4520_/A0 _7287_/Q _4532_/S VGND VGND VPWR VPWR _7319_/D sky130_fd_sc_hd__mux2_2
XFILLER_116_137 VGND VGND VPWR VPWR sky130_fd_sc_hd__decap_3
XFILLER_7_261 VGND VGND VPWR VPWR sky130_fd_sc_hd__decap_3
X_4451_ _4451_/A _4451_/B VGND VGND VPWR VPWR _4765_/B sky130_fd_sc_hd__nor2_2
X_7170_ _7332_/CLK _7170_/D _6450_/Y VGND VGND VPWR VPWR _7170_/Q sky130_fd_sc_hd__dfrtp_2
X_3402_ _3385_/Y _3401_/X _4284_/A2 VGND VGND VPWR VPWR _3421_/C sky130_fd_sc_hd__a21oi_4
X_4382_ _4950_/A _4967_/B VGND VGND VPWR VPWR _4383_/C sky130_fd_sc_hd__nor2_2
XFILLER_98_533 VGND VGND VPWR VPWR sky130_fd_sc_hd__decap_3
XFILLER_98_522 VGND VGND VPWR VPWR sky130_fd_sc_hd__decap_3
XFILLER_112_321 VGND VGND VPWR VPWR sky130_fd_sc_hd__decap_3
XFILLER_98_566 VGND VGND VPWR VPWR sky130_fd_sc_hd__decap_3
XFILLER_100_516 VGND VGND VPWR VPWR sky130_fd_sc_hd__decap_3
XFILLER_105_18 VGND VGND VPWR VPWR sky130_fd_sc_hd__decap_3
XFILLER_112_365 VGND VGND VPWR VPWR sky130_fd_sc_hd__decap_3
XFILLER_112_376 VGND VGND VPWR VPWR sky130_fd_sc_hd__decap_3
XFILLER_39_600 VGND VGND VPWR VPWR sky130_fd_sc_hd__decap_3
XPHY_EDGE_ROW_7_Right_7 VGND VGND VPWR VPWR sky130_fd_sc_hd__decap_3
XFILLER_39_644 VGND VGND VPWR VPWR sky130_fd_sc_hd__decap_3
XFILLER_66_430 VGND VGND VPWR VPWR sky130_fd_sc_hd__fill_2
XFILLER_85_249 VGND VGND VPWR VPWR sky130_fd_sc_hd__decap_3
X_5003_ _5003_/A _5003_/B VGND VGND VPWR VPWR _5003_/X sky130_fd_sc_hd__or2_2
XFILLER_39_688 VGND VGND VPWR VPWR sky130_fd_sc_hd__decap_3
XFILLER_53_113 VGND VGND VPWR VPWR sky130_fd_sc_hd__fill_2
XFILLER_54_625 VGND VGND VPWR VPWR sky130_fd_sc_hd__decap_3
XFILLER_66_474 VGND VGND VPWR VPWR sky130_fd_sc_hd__fill_2
XFILLER_54_669 VGND VGND VPWR VPWR sky130_fd_sc_hd__decap_3
XFILLER_93_293 VGND VGND VPWR VPWR sky130_fd_sc_hd__fill_2
X_6954_ _6954_/CLK _6954_/D VGND VGND VPWR VPWR _6954_/Q sky130_fd_sc_hd__dfxtp_2
XFILLER_22_544 VGND VGND VPWR VPWR sky130_fd_sc_hd__decap_3
X_6885_ _6941_/CLK _6885_/D VGND VGND VPWR VPWR _6885_/Q sky130_fd_sc_hd__dfxtp_2
XTAP_TAPCELL_ROW_24_539 VGND VPWR sky130_fd_sc_hd__tapvpwrvgnd_1
XFILLER_22_577 VGND VGND VPWR VPWR sky130_fd_sc_hd__decap_3
XFILLER_108_616 VGND VGND VPWR VPWR sky130_fd_sc_hd__decap_3
X_4718_ _4718_/A0 _4716_/X _4837_/S VGND VGND VPWR VPWR _7278_/D sky130_fd_sc_hd__mux2_4
XFILLER_107_137 VGND VGND VPWR VPWR sky130_fd_sc_hd__decap_3
X_4649_ _4649_/A _4649_/B _4425_/C VGND VGND VPWR VPWR _4652_/A sky130_fd_sc_hd__nor3b_2
XFILLER_116_682 VGND VGND VPWR VPWR sky130_fd_sc_hd__fill_1
X_7368_ _7368_/CLK _7368_/D _6648_/Y VGND VGND VPWR VPWR _7368_/Q sky130_fd_sc_hd__dfrtp_2
Xhold740 _6900_/Q VGND VGND VPWR VPWR _6900_/D sky130_fd_sc_hd__dlygate4sd3_1
Xhold751 _6885_/Q VGND VGND VPWR VPWR _6885_/D sky130_fd_sc_hd__dlygate4sd3_1
Xhold762 _6729_/Q VGND VGND VPWR VPWR _6729_/D sky130_fd_sc_hd__dlygate4sd3_1
Xhold773 _6918_/Q VGND VGND VPWR VPWR _6918_/D sky130_fd_sc_hd__dlygate4sd3_1
XTAP_TAPCELL_ROW_73_1132 VGND VPWR sky130_fd_sc_hd__tapvpwrvgnd_1
XFILLER_103_343 VGND VGND VPWR VPWR sky130_fd_sc_hd__decap_3
XFILLER_115_181 VGND VGND VPWR VPWR sky130_fd_sc_hd__decap_3
XFILLER_89_544 VGND VGND VPWR VPWR sky130_fd_sc_hd__decap_3
X_7299_ _7365_/CLK _7299_/D _6579_/Y VGND VGND VPWR VPWR _7299_/Q sky130_fd_sc_hd__dfrtp_2
Xhold784 _6824_/Q VGND VGND VPWR VPWR _6824_/D sky130_fd_sc_hd__dlygate4sd3_1
Xhold795 _6852_/Q VGND VGND VPWR VPWR _6852_/D sky130_fd_sc_hd__dlygate4sd3_1
X_6319_ _6673_/A VGND VGND VPWR VPWR _6319_/Y sky130_fd_sc_hd__inv_2
XFILLER_89_588 VGND VGND VPWR VPWR sky130_fd_sc_hd__decap_3
XFILLER_45_603 VGND VGND VPWR VPWR sky130_fd_sc_hd__decap_3
XFILLER_57_452 VGND VGND VPWR VPWR sky130_fd_sc_hd__fill_2
XFILLER_84_271 VGND VGND VPWR VPWR sky130_fd_sc_hd__decap_3
XTAP_TAPCELL_ROW_4_297 VGND VPWR sky130_fd_sc_hd__tapvpwrvgnd_1
XFILLER_17_349 VGND VGND VPWR VPWR sky130_fd_sc_hd__decap_3
XFILLER_45_647 VGND VGND VPWR VPWR sky130_fd_sc_hd__decap_3
XFILLER_72_444 VGND VGND VPWR VPWR sky130_fd_sc_hd__decap_3
XFILLER_13_500 VGND VGND VPWR VPWR sky130_fd_sc_hd__decap_3
XFILLER_60_628 VGND VGND VPWR VPWR sky130_fd_sc_hd__decap_3
XFILLER_72_477 VGND VGND VPWR VPWR sky130_fd_sc_hd__decap_3
XTAP_TAPCELL_ROW_84_1261 VGND VPWR sky130_fd_sc_hd__tapvpwrvgnd_1
XFILLER_111_72 VGND VGND VPWR VPWR sky130_fd_sc_hd__decap_3
XFILLER_25_393 VGND VGND VPWR VPWR sky130_fd_sc_hd__fill_2
XFILLER_13_555 VGND VGND VPWR VPWR sky130_fd_sc_hd__decap_3
XFILLER_71_65 VGND VGND VPWR VPWR sky130_fd_sc_hd__fill_1
XFILLER_9_526 VGND VGND VPWR VPWR sky130_fd_sc_hd__decap_3
XFILLER_13_588 VGND VGND VPWR VPWR sky130_fd_sc_hd__decap_3
XFILLER_71_87 VGND VGND VPWR VPWR sky130_fd_sc_hd__fill_2
XFILLER_9_559 VGND VGND VPWR VPWR sky130_fd_sc_hd__fill_1
XFILLER_114_619 VGND VGND VPWR VPWR sky130_fd_sc_hd__decap_3
XFILLER_4_220 VGND VGND VPWR VPWR sky130_fd_sc_hd__decap_3
XFILLER_58_9 VGND VGND VPWR VPWR sky130_fd_sc_hd__fill_1
XFILLER_107_671 VGND VGND VPWR VPWR sky130_fd_sc_hd__fill_1
XFILLER_107_682 VGND VGND VPWR VPWR sky130_fd_sc_hd__decap_3
XFILLER_4_253 VGND VGND VPWR VPWR sky130_fd_sc_hd__fill_2
XFILLER_4_264 VGND VGND VPWR VPWR sky130_fd_sc_hd__decap_3
XTAP_TAPCELL_ROW_95_1390 VGND VPWR sky130_fd_sc_hd__tapvpwrvgnd_1
XFILLER_20_91 VGND VGND VPWR VPWR sky130_fd_sc_hd__decap_3
XFILLER_67_205 VGND VGND VPWR VPWR sky130_fd_sc_hd__decap_3
XFILLER_95_503 VGND VGND VPWR VPWR sky130_fd_sc_hd__fill_1
XFILLER_95_514 VGND VGND VPWR VPWR sky130_fd_sc_hd__decap_3
XFILLER_67_238 VGND VGND VPWR VPWR sky130_fd_sc_hd__decap_3
XFILLER_95_547 VGND VGND VPWR VPWR sky130_fd_sc_hd__decap_3
XFILLER_48_430 VGND VGND VPWR VPWR sky130_fd_sc_hd__fill_1
XFILLER_48_452 VGND VGND VPWR VPWR sky130_fd_sc_hd__decap_3
XFILLER_82_208 VGND VGND VPWR VPWR sky130_fd_sc_hd__decap_3
XFILLER_35_113 VGND VGND VPWR VPWR sky130_fd_sc_hd__decap_3
XFILLER_36_625 VGND VGND VPWR VPWR sky130_fd_sc_hd__decap_3
XFILLER_36_669 VGND VGND VPWR VPWR sky130_fd_sc_hd__decap_3
XFILLER_75_293 VGND VGND VPWR VPWR sky130_fd_sc_hd__fill_1
Xplace400 _4300_/B VGND VGND VPWR VPWR _4528_/B sky130_fd_sc_hd__buf_2
Xplace411 _4261_/A2 VGND VGND VPWR VPWR _4419_/B1 sky130_fd_sc_hd__buf_2
Xplace422 _3964_/S VGND VGND VPWR VPWR _3958_/S sky130_fd_sc_hd__buf_2
XFILLER_23_308 VGND VGND VPWR VPWR sky130_fd_sc_hd__decap_3
XFILLER_51_606 VGND VGND VPWR VPWR sky130_fd_sc_hd__decap_3
XFILLER_51_617 VGND VGND VPWR VPWR sky130_fd_sc_hd__decap_3
XFILLER_90_274 VGND VGND VPWR VPWR sky130_fd_sc_hd__decap_3
Xplace433 _3344_/Y VGND VGND VPWR VPWR _4677_/B sky130_fd_sc_hd__buf_2
Xplace444 _4331_/A2 VGND VGND VPWR VPWR _4414_/A2 sky130_fd_sc_hd__buf_2
Xplace455 _6980_/Q VGND VGND VPWR VPWR _3365_/A sky130_fd_sc_hd__buf_2
XFILLER_16_371 VGND VGND VPWR VPWR sky130_fd_sc_hd__decap_3
XFILLER_16_382 VGND VGND VPWR VPWR sky130_fd_sc_hd__fill_2
XFILLER_16_393 VGND VGND VPWR VPWR sky130_fd_sc_hd__decap_3
XFILLER_31_330 VGND VGND VPWR VPWR sky130_fd_sc_hd__decap_3
XFILLER_91_3 VGND VGND VPWR VPWR sky130_fd_sc_hd__decap_3
X_6670_ _6672_/A VGND VGND VPWR VPWR _6670_/Y sky130_fd_sc_hd__inv_2
X_3882_ _6974_/Q _3889_/A2 _3889_/B1 _6969_/Q _3881_/X VGND VGND VPWR VPWR _3882_/X
+ sky130_fd_sc_hd__a221o_2
XTAP_TAPCELL_ROW_21_509 VGND VPWR sky130_fd_sc_hd__tapvpwrvgnd_1
X_5621_ _5621_/A VGND VGND VPWR VPWR _5622_/A sky130_fd_sc_hd__inv_2
XFILLER_8_581 VGND VGND VPWR VPWR sky130_fd_sc_hd__decap_3
XFILLER_8_592 VGND VGND VPWR VPWR sky130_fd_sc_hd__decap_3
X_4503_ _4503_/A0 _7296_/Q _4517_/S VGND VGND VPWR VPWR _7328_/D sky130_fd_sc_hd__mux2_2
X_7222_ _7317_/CLK _7222_/D _6502_/Y VGND VGND VPWR VPWR _7222_/Q sky130_fd_sc_hd__dfrtp_2
X_4434_ _7111_/Q _4434_/A2 _4434_/B1 _7143_/Q _4433_/X VGND VGND VPWR VPWR _4434_/X
+ sky130_fd_sc_hd__a221o_2
XFILLER_113_641 VGND VGND VPWR VPWR sky130_fd_sc_hd__decap_3
X_7153_ _7351_/CLK _7153_/D _6433_/Y VGND VGND VPWR VPWR _7153_/Q sky130_fd_sc_hd__dfrtp_2
X_4365_ _4365_/A _4365_/B _4365_/C VGND VGND VPWR VPWR _4365_/X sky130_fd_sc_hd__and3_2
XFILLER_113_685 VGND VGND VPWR VPWR sky130_fd_sc_hd__decap_3
X_7084_ _7403_/CLK _7084_/D _6364_/Y VGND VGND VPWR VPWR _7084_/Q sky130_fd_sc_hd__dfrtp_2
X_3316_ _3365_/A _6983_/Q VGND VGND VPWR VPWR _3332_/B sky130_fd_sc_hd__nor2b_2
XFILLER_100_302 VGND VGND VPWR VPWR sky130_fd_sc_hd__decap_3
XFILLER_100_324 VGND VGND VPWR VPWR sky130_fd_sc_hd__decap_3
XFILLER_112_195 VGND VGND VPWR VPWR sky130_fd_sc_hd__fill_1
XFILLER_86_536 VGND VGND VPWR VPWR sky130_fd_sc_hd__decap_3
X_4296_ _4292_/A _3591_/Y _4295_/X VGND VGND VPWR VPWR _4297_/B sky130_fd_sc_hd__a21oi_2
XFILLER_100_357 VGND VGND VPWR VPWR sky130_fd_sc_hd__decap_3
XFILLER_86_569 VGND VGND VPWR VPWR sky130_fd_sc_hd__decap_3
XFILLER_27_603 VGND VGND VPWR VPWR sky130_fd_sc_hd__decap_3
XFILLER_66_271 VGND VGND VPWR VPWR sky130_fd_sc_hd__decap_3
XFILLER_27_647 VGND VGND VPWR VPWR sky130_fd_sc_hd__decap_3
XFILLER_66_293 VGND VGND VPWR VPWR sky130_fd_sc_hd__decap_3
XTAP_TAPCELL_ROW_1_267 VGND VPWR sky130_fd_sc_hd__tapvpwrvgnd_1
XTAP_TAPCELL_ROW_107_1537 VGND VPWR sky130_fd_sc_hd__tapvpwrvgnd_1
XFILLER_14_319 VGND VGND VPWR VPWR sky130_fd_sc_hd__decap_3
XFILLER_42_628 VGND VGND VPWR VPWR sky130_fd_sc_hd__decap_3
XFILLER_54_477 VGND VGND VPWR VPWR sky130_fd_sc_hd__fill_1
XFILLER_54_499 VGND VGND VPWR VPWR sky130_fd_sc_hd__decap_3
XFILLER_81_296 VGND VGND VPWR VPWR sky130_fd_sc_hd__decap_3
X_6937_ _6941_/CLK _6937_/D VGND VGND VPWR VPWR _6937_/Q sky130_fd_sc_hd__dfxtp_2
XTAP_TAPCELL_ROW_37_697 VGND VPWR sky130_fd_sc_hd__tapvpwrvgnd_1
XFILLER_22_352 VGND VGND VPWR VPWR sky130_fd_sc_hd__decap_3
X_6868_ _7378_/CLK _6868_/D VGND VGND VPWR VPWR _6868_/Q sky130_fd_sc_hd__dfxtp_2
XFILLER_50_672 VGND VGND VPWR VPWR sky130_fd_sc_hd__decap_3
XFILLER_10_536 VGND VGND VPWR VPWR sky130_fd_sc_hd__decap_3
XFILLER_10_569 VGND VGND VPWR VPWR sky130_fd_sc_hd__decap_3
XFILLER_41_57 VGND VGND VPWR VPWR sky130_fd_sc_hd__fill_2
XFILLER_6_507 VGND VGND VPWR VPWR sky130_fd_sc_hd__decap_3
X_6799_ _6941_/CLK _6799_/D VGND VGND VPWR VPWR _6799_/Q sky130_fd_sc_hd__dfxtp_2
XFILLER_108_424 VGND VGND VPWR VPWR sky130_fd_sc_hd__decap_3
XFILLER_108_457 VGND VGND VPWR VPWR sky130_fd_sc_hd__decap_3
XFILLER_1_201 VGND VGND VPWR VPWR sky130_fd_sc_hd__decap_3
XFILLER_1_234 VGND VGND VPWR VPWR sky130_fd_sc_hd__fill_1
Xhold581 _6904_/Q VGND VGND VPWR VPWR _6904_/D sky130_fd_sc_hd__dlygate4sd3_1
XTAP_TAPCELL_ROW_9_356 VGND VPWR sky130_fd_sc_hd__tapvpwrvgnd_1
XFILLER_104_663 VGND VGND VPWR VPWR sky130_fd_sc_hd__decap_3
XFILLER_89_374 VGND VGND VPWR VPWR sky130_fd_sc_hd__decap_3
Xhold592 _6810_/Q VGND VGND VPWR VPWR _6810_/D sky130_fd_sc_hd__dlygate4sd3_1
XFILLER_106_50 VGND VGND VPWR VPWR sky130_fd_sc_hd__decap_3
XFILLER_2_18 VGND VGND VPWR VPWR sky130_fd_sc_hd__fill_2
XFILLER_2_29 VGND VGND VPWR VPWR sky130_fd_sc_hd__decap_3
XFILLER_66_21 VGND VGND VPWR VPWR sky130_fd_sc_hd__decap_3
XFILLER_77_558 VGND VGND VPWR VPWR sky130_fd_sc_hd__fill_2
XFILLER_18_625 VGND VGND VPWR VPWR sky130_fd_sc_hd__decap_3
XFILLER_66_65 VGND VGND VPWR VPWR sky130_fd_sc_hd__decap_3
XFILLER_92_517 VGND VGND VPWR VPWR sky130_fd_sc_hd__decap_3
XFILLER_92_539 VGND VGND VPWR VPWR sky130_fd_sc_hd__decap_3
XFILLER_18_669 VGND VGND VPWR VPWR sky130_fd_sc_hd__decap_3
XFILLER_45_422 VGND VGND VPWR VPWR sky130_fd_sc_hd__fill_1
XFILLER_57_293 VGND VGND VPWR VPWR sky130_fd_sc_hd__decap_3
XFILLER_72_230 VGND VGND VPWR VPWR sky130_fd_sc_hd__decap_3
XFILLER_85_591 VGND VGND VPWR VPWR sky130_fd_sc_hd__decap_3
XFILLER_33_606 VGND VGND VPWR VPWR sky130_fd_sc_hd__decap_3
XFILLER_33_617 VGND VGND VPWR VPWR sky130_fd_sc_hd__decap_3
XFILLER_60_403 VGND VGND VPWR VPWR sky130_fd_sc_hd__decap_3
XFILLER_32_149 VGND VGND VPWR VPWR sky130_fd_sc_hd__decap_3
XFILLER_41_650 VGND VGND VPWR VPWR sky130_fd_sc_hd__decap_3
XFILLER_13_396 VGND VGND VPWR VPWR sky130_fd_sc_hd__fill_1
XFILLER_9_345 VGND VGND VPWR VPWR sky130_fd_sc_hd__fill_2
XFILLER_114_416 VGND VGND VPWR VPWR sky130_fd_sc_hd__decap_3
XFILLER_114_427 VGND VGND VPWR VPWR sky130_fd_sc_hd__decap_3
XFILLER_31_90 VGND VGND VPWR VPWR sky130_fd_sc_hd__decap_3
XFILLER_56_6 VGND VGND VPWR VPWR sky130_fd_sc_hd__decap_3
XFILLER_5_573 VGND VGND VPWR VPWR sky130_fd_sc_hd__decap_3
XFILLER_99_116 VGND VGND VPWR VPWR sky130_fd_sc_hd__fill_1
XFILLER_68_514 VGND VGND VPWR VPWR sky130_fd_sc_hd__fill_1
X_4150_ _7234_/Q _4414_/A2 _4093_/B _7362_/Q VGND VGND VPWR VPWR _4150_/X sky130_fd_sc_hd__a22o_2
XFILLER_110_622 VGND VGND VPWR VPWR sky130_fd_sc_hd__decap_3
XFILLER_110_666 VGND VGND VPWR VPWR sky130_fd_sc_hd__decap_3
X_4081_ _4451_/A _4451_/B VGND VGND VPWR VPWR _4081_/X sky130_fd_sc_hd__or2b_2
XFILLER_95_388 VGND VGND VPWR VPWR sky130_fd_sc_hd__decap_3
XFILLER_48_293 VGND VGND VPWR VPWR sky130_fd_sc_hd__decap_3
XFILLER_24_628 VGND VGND VPWR VPWR sky130_fd_sc_hd__decap_3
XFILLER_36_477 VGND VGND VPWR VPWR sky130_fd_sc_hd__decap_3
XFILLER_63_252 VGND VGND VPWR VPWR sky130_fd_sc_hd__decap_3
XFILLER_91_561 VGND VGND VPWR VPWR sky130_fd_sc_hd__decap_3
XFILLER_91_594 VGND VGND VPWR VPWR sky130_fd_sc_hd__decap_3
X_4983_ _4983_/A _4983_/B _4983_/C VGND VGND VPWR VPWR _4983_/X sky130_fd_sc_hd__and3_2
XFILLER_51_469 VGND VGND VPWR VPWR sky130_fd_sc_hd__decap_3
Xplace296 _3651_/Y VGND VGND VPWR VPWR _3891_/A2 sky130_fd_sc_hd__buf_2
Xplace285 _3892_/A2 VGND VGND VPWR VPWR _3879_/A2 sky130_fd_sc_hd__buf_2
Xplace274 _3888_/B1 VGND VGND VPWR VPWR _3883_/B1 sky130_fd_sc_hd__buf_2
X_6722_ clkload8/A _6722_/D VGND VGND VPWR VPWR _6722_/Q sky130_fd_sc_hd__dfxtp_2
XTAP_TAPCELL_ROW_34_656 VGND VPWR sky130_fd_sc_hd__tapvpwrvgnd_1
XFILLER_32_672 VGND VGND VPWR VPWR sky130_fd_sc_hd__decap_3
X_6653_ _6653_/A VGND VGND VPWR VPWR _6653_/Y sky130_fd_sc_hd__inv_2
XTAP_TAPCELL_ROW_62_998 VGND VPWR sky130_fd_sc_hd__tapvpwrvgnd_1
XTAP_TAPCELL_ROW_102_1478 VGND VPWR sky130_fd_sc_hd__tapvpwrvgnd_1
X_6584_ _6616_/A VGND VGND VPWR VPWR _6584_/Y sky130_fd_sc_hd__inv_2
X_3796_ _6726_/Q _3879_/A2 _3879_/B1 _6976_/Q _3795_/X VGND VGND VPWR VPWR _3796_/X
+ sky130_fd_sc_hd__a221o_2
XFILLER_105_427 VGND VGND VPWR VPWR sky130_fd_sc_hd__fill_2
XFILLER_105_449 VGND VGND VPWR VPWR sky130_fd_sc_hd__fill_1
X_7205_ _7395_/CLK _7205_/D _6485_/Y VGND VGND VPWR VPWR _7205_/Q sky130_fd_sc_hd__dfrtp_2
X_4417_ _7304_/Q _4823_/S _4434_/A2 _7112_/Q _4416_/X VGND VGND VPWR VPWR _4417_/X
+ sky130_fd_sc_hd__a221o_2
XFILLER_101_600 VGND VGND VPWR VPWR sky130_fd_sc_hd__decap_3
XTAP_TAPCELL_ROW_6_326 VGND VPWR sky130_fd_sc_hd__tapvpwrvgnd_1
XFILLER_99_650 VGND VGND VPWR VPWR sky130_fd_sc_hd__decap_3
XFILLER_113_482 VGND VGND VPWR VPWR sky130_fd_sc_hd__decap_3
XFILLER_59_514 VGND VGND VPWR VPWR sky130_fd_sc_hd__fill_2
XFILLER_86_300 VGND VGND VPWR VPWR sky130_fd_sc_hd__decap_3
X_7136_ _7364_/CLK _7136_/D _6416_/Y VGND VGND VPWR VPWR _7136_/Q sky130_fd_sc_hd__dfrtp_2
X_4348_ _7161_/Q _4348_/A2 _4348_/B1 _7129_/Q _4347_/X VGND VGND VPWR VPWR _4348_/X
+ sky130_fd_sc_hd__a221o_2
XFILLER_100_132 VGND VGND VPWR VPWR sky130_fd_sc_hd__decap_3
XFILLER_101_644 VGND VGND VPWR VPWR sky130_fd_sc_hd__decap_3
XFILLER_86_344 VGND VGND VPWR VPWR sky130_fd_sc_hd__decap_3
X_7067_ _7392_/CLK _7067_/D _6347_/Y VGND VGND VPWR VPWR _7067_/Q sky130_fd_sc_hd__dfrtp_2
X_4279_ _7318_/Q _3987_/S _4279_/B1 _7126_/Q VGND VGND VPWR VPWR _4279_/X sky130_fd_sc_hd__a22o_2
XFILLER_101_688 VGND VGND VPWR VPWR sky130_fd_sc_hd__decap_3
XFILLER_39_260 VGND VGND VPWR VPWR sky130_fd_sc_hd__decap_3
XFILLER_39_271 VGND VGND VPWR VPWR sky130_fd_sc_hd__decap_3
XFILLER_46_208 VGND VGND VPWR VPWR sky130_fd_sc_hd__decap_3
XFILLER_74_539 VGND VGND VPWR VPWR sky130_fd_sc_hd__decap_3
XFILLER_27_433 VGND VGND VPWR VPWR sky130_fd_sc_hd__decap_3
XFILLER_27_444 VGND VGND VPWR VPWR sky130_fd_sc_hd__decap_3
XFILLER_67_591 VGND VGND VPWR VPWR sky130_fd_sc_hd__decap_3
XFILLER_15_606 VGND VGND VPWR VPWR sky130_fd_sc_hd__decap_3
XFILLER_15_617 VGND VGND VPWR VPWR sky130_fd_sc_hd__decap_3
XFILLER_27_477 VGND VGND VPWR VPWR sky130_fd_sc_hd__fill_1
XFILLER_82_572 VGND VGND VPWR VPWR sky130_fd_sc_hd__decap_3
XTAP_TAPCELL_ROW_68_1064 VGND VPWR sky130_fd_sc_hd__tapvpwrvgnd_1
XFILLER_42_414 VGND VGND VPWR VPWR sky130_fd_sc_hd__fill_1
XFILLER_42_436 VGND VGND VPWR VPWR sky130_fd_sc_hd__decap_3
XFILLER_23_650 VGND VGND VPWR VPWR sky130_fd_sc_hd__decap_3
XFILLER_42_458 VGND VGND VPWR VPWR sky130_fd_sc_hd__decap_3
XTAP_TAPCELL_ROW_81_1220 VGND VPWR sky130_fd_sc_hd__tapvpwrvgnd_1
XFILLER_10_355 VGND VGND VPWR VPWR sky130_fd_sc_hd__decap_3
XFILLER_108_221 VGND VGND VPWR VPWR sky130_fd_sc_hd__fill_1
XFILLER_2_510 VGND VGND VPWR VPWR sky130_fd_sc_hd__decap_3
XFILLER_111_408 VGND VGND VPWR VPWR sky130_fd_sc_hd__decap_3
XFILLER_2_554 VGND VGND VPWR VPWR sky130_fd_sc_hd__decap_3
XFILLER_96_108 VGND VGND VPWR VPWR sky130_fd_sc_hd__decap_3
XTAP_TAPCELL_ROW_92_1360 VGND VPWR sky130_fd_sc_hd__tapvpwrvgnd_1
XFILLER_97_609 VGND VGND VPWR VPWR sky130_fd_sc_hd__decap_3
XFILLER_2_587 VGND VGND VPWR VPWR sky130_fd_sc_hd__fill_1
XFILLER_2_598 VGND VGND VPWR VPWR sky130_fd_sc_hd__decap_3
XFILLER_77_333 VGND VGND VPWR VPWR sky130_fd_sc_hd__decap_3
XFILLER_77_344 VGND VGND VPWR VPWR sky130_fd_sc_hd__decap_3
XFILLER_77_97 VGND VGND VPWR VPWR sky130_fd_sc_hd__decap_3
XFILLER_37_208 VGND VGND VPWR VPWR sky130_fd_sc_hd__fill_2
XFILLER_58_580 VGND VGND VPWR VPWR sky130_fd_sc_hd__decap_3
XFILLER_92_358 VGND VGND VPWR VPWR sky130_fd_sc_hd__decap_3
XFILLER_18_477 VGND VGND VPWR VPWR sky130_fd_sc_hd__fill_2
XFILLER_45_252 VGND VGND VPWR VPWR sky130_fd_sc_hd__decap_3
XFILLER_45_263 VGND VGND VPWR VPWR sky130_fd_sc_hd__decap_3
XFILLER_73_561 VGND VGND VPWR VPWR sky130_fd_sc_hd__decap_3
XFILLER_60_200 VGND VGND VPWR VPWR sky130_fd_sc_hd__decap_3
XFILLER_73_594 VGND VGND VPWR VPWR sky130_fd_sc_hd__decap_3
XFILLER_93_85 VGND VGND VPWR VPWR sky130_fd_sc_hd__decap_3
XFILLER_21_609 VGND VGND VPWR VPWR sky130_fd_sc_hd__decap_3
XFILLER_60_233 VGND VGND VPWR VPWR sky130_fd_sc_hd__decap_3
XFILLER_14_672 VGND VGND VPWR VPWR sky130_fd_sc_hd__decap_3
XFILLER_60_288 VGND VGND VPWR VPWR sky130_fd_sc_hd__decap_3
XTAP_TAPCELL_ROW_31_626 VGND VPWR sky130_fd_sc_hd__tapvpwrvgnd_1
XFILLER_41_491 VGND VGND VPWR VPWR sky130_fd_sc_hd__decap_3
X_3650_ _3991_/B VGND VGND VPWR VPWR _3665_/A sky130_fd_sc_hd__inv_2
X_3581_ _7156_/Q _3409_/X _3579_/X _3580_/X VGND VGND VPWR VPWR _3583_/B sky130_fd_sc_hd__a211o_2
XTAP_TAPCELL_ROW_11_383 VGND VPWR sky130_fd_sc_hd__tapvpwrvgnd_1
XFILLER_54_3 VGND VGND VPWR VPWR sky130_fd_sc_hd__decap_3
XFILLER_114_224 VGND VGND VPWR VPWR sky130_fd_sc_hd__fill_1
X_5251_ _5251_/A0 _4899_/X _5262_/S VGND VGND VPWR VPWR _7204_/D sky130_fd_sc_hd__mux2_2
XFILLER_114_257 VGND VGND VPWR VPWR sky130_fd_sc_hd__decap_3
X_4202_ _4202_/A VGND VGND VPWR VPWR _4203_/C sky130_fd_sc_hd__inv_2
XFILLER_96_631 VGND VGND VPWR VPWR sky130_fd_sc_hd__decap_3
X_5182_ _5182_/A _5190_/B VGND VGND VPWR VPWR _7237_/D sky130_fd_sc_hd__and2_2
XFILLER_110_430 VGND VGND VPWR VPWR sky130_fd_sc_hd__decap_3
X_4133_ _7363_/Q _4093_/B _4436_/B1 _7171_/Q VGND VGND VPWR VPWR _4133_/X sky130_fd_sc_hd__a22o_2
XFILLER_110_463 VGND VGND VPWR VPWR sky130_fd_sc_hd__decap_3
XFILLER_56_539 VGND VGND VPWR VPWR sky130_fd_sc_hd__decap_3
XFILLER_83_303 VGND VGND VPWR VPWR sky130_fd_sc_hd__fill_2
XFILLER_96_675 VGND VGND VPWR VPWR sky130_fd_sc_hd__decap_3
X_4064_ _7372_/Q _4394_/B _4946_/S _7308_/Q _4063_/X VGND VGND VPWR VPWR _4064_/X
+ sky130_fd_sc_hd__a221o_2
XTAP_TAPCELL_ROW_39_715 VGND VPWR sky130_fd_sc_hd__tapvpwrvgnd_1
XFILLER_113_29 VGND VGND VPWR VPWR sky130_fd_sc_hd__decap_3
XFILLER_49_591 VGND VGND VPWR VPWR sky130_fd_sc_hd__decap_3
XFILLER_83_325 VGND VGND VPWR VPWR sky130_fd_sc_hd__decap_3
XFILLER_95_185 VGND VGND VPWR VPWR sky130_fd_sc_hd__fill_2
XFILLER_36_230 VGND VGND VPWR VPWR sky130_fd_sc_hd__decap_3
XFILLER_51_211 VGND VGND VPWR VPWR sky130_fd_sc_hd__decap_3
XFILLER_64_572 VGND VGND VPWR VPWR sky130_fd_sc_hd__decap_3
XTAP_TAPCELL_ROW_19_483 VGND VPWR sky130_fd_sc_hd__tapvpwrvgnd_1
XFILLER_51_266 VGND VGND VPWR VPWR sky130_fd_sc_hd__decap_3
X_6705_ _6965_/CLK _6705_/D VGND VGND VPWR VPWR _6705_/Q sky130_fd_sc_hd__dfxtp_2
XFILLER_20_631 VGND VGND VPWR VPWR sky130_fd_sc_hd__decap_3
X_4897_ _4896_/A _4896_/B _4896_/Y _4983_/A VGND VGND VPWR VPWR _4897_/X sky130_fd_sc_hd__o211a_2
X_3917_ _6689_/Q _3917_/A2 _3925_/B1 _6867_/Q VGND VGND VPWR VPWR _3917_/X sky130_fd_sc_hd__a22o_2
XFILLER_20_675 VGND VGND VPWR VPWR sky130_fd_sc_hd__decap_3
X_6636_ _6636_/A VGND VGND VPWR VPWR _6636_/Y sky130_fd_sc_hd__inv_2
X_3848_ _6907_/Q _3879_/A2 _3893_/B1 _6851_/Q VGND VGND VPWR VPWR _3848_/X sky130_fd_sc_hd__a22o_2
X_6567_ _6567_/A VGND VGND VPWR VPWR _6567_/Y sky130_fd_sc_hd__inv_2
X_3779_ _6794_/Q _3922_/A2 _3893_/B1 _6704_/Q _3778_/X VGND VGND VPWR VPWR _3779_/X
+ sky130_fd_sc_hd__a221o_2
XFILLER_3_318 VGND VGND VPWR VPWR sky130_fd_sc_hd__fill_2
XTAP_TAPCELL_ROW_115_1636 VGND VPWR sky130_fd_sc_hd__tapvpwrvgnd_1
XFILLER_105_213 VGND VGND VPWR VPWR sky130_fd_sc_hd__fill_1
X_6498_ _6635_/A VGND VGND VPWR VPWR _6498_/Y sky130_fd_sc_hd__inv_2
XFILLER_79_609 VGND VGND VPWR VPWR sky130_fd_sc_hd__decap_3
Xoutput461 _5662_/B VGND VGND VPWR VPWR alu_result_out[11] sky130_fd_sc_hd__clkdlybuf4s25_1
XFILLER_59_311 VGND VGND VPWR VPWR sky130_fd_sc_hd__decap_3
XFILLER_87_620 VGND VGND VPWR VPWR sky130_fd_sc_hd__decap_3
Xoutput494 _3525_/A VGND VGND VPWR VPWR instruction_out[13] sky130_fd_sc_hd__clkdlybuf4s25_1
Xoutput483 _5654_/Y VGND VGND VPWR VPWR alu_result_out[31] sky130_fd_sc_hd__clkdlybuf4s25_1
Xoutput472 _5656_/B VGND VGND VPWR VPWR alu_result_out[21] sky130_fd_sc_hd__clkdlybuf4s25_1
XFILLER_86_130 VGND VGND VPWR VPWR sky130_fd_sc_hd__decap_3
XFILLER_86_141 VGND VGND VPWR VPWR sky130_fd_sc_hd__decap_3
XFILLER_87_653 VGND VGND VPWR VPWR sky130_fd_sc_hd__decap_3
X_7119_ _7349_/CLK _7119_/D _6399_/Y VGND VGND VPWR VPWR _7119_/Q sky130_fd_sc_hd__dfrtp_2
XFILLER_101_463 VGND VGND VPWR VPWR sky130_fd_sc_hd__decap_3
XFILLER_101_474 VGND VGND VPWR VPWR sky130_fd_sc_hd__decap_3
XFILLER_74_303 VGND VGND VPWR VPWR sky130_fd_sc_hd__decap_3
XFILLER_86_174 VGND VGND VPWR VPWR sky130_fd_sc_hd__decap_3
XFILLER_59_399 VGND VGND VPWR VPWR sky130_fd_sc_hd__decap_3
XFILLER_74_336 VGND VGND VPWR VPWR sky130_fd_sc_hd__decap_3
XFILLER_103_51 VGND VGND VPWR VPWR sky130_fd_sc_hd__decap_3
XFILLER_27_241 VGND VGND VPWR VPWR sky130_fd_sc_hd__decap_3
XFILLER_55_561 VGND VGND VPWR VPWR sky130_fd_sc_hd__decap_3
XFILLER_103_84 VGND VGND VPWR VPWR sky130_fd_sc_hd__fill_1
XFILLER_27_274 VGND VGND VPWR VPWR sky130_fd_sc_hd__decap_3
XFILLER_27_296 VGND VGND VPWR VPWR sky130_fd_sc_hd__decap_3
XFILLER_55_594 VGND VGND VPWR VPWR sky130_fd_sc_hd__decap_3
XFILLER_63_33 VGND VGND VPWR VPWR sky130_fd_sc_hd__fill_1
XFILLER_42_233 VGND VGND VPWR VPWR sky130_fd_sc_hd__fill_1
XFILLER_70_531 VGND VGND VPWR VPWR sky130_fd_sc_hd__fill_1
XFILLER_70_564 VGND VGND VPWR VPWR sky130_fd_sc_hd__decap_3
XFILLER_42_288 VGND VGND VPWR VPWR sky130_fd_sc_hd__decap_3
XFILLER_11_620 VGND VGND VPWR VPWR sky130_fd_sc_hd__decap_3
XFILLER_23_491 VGND VGND VPWR VPWR sky130_fd_sc_hd__decap_3
XFILLER_10_141 VGND VGND VPWR VPWR sky130_fd_sc_hd__decap_3
XFILLER_11_653 VGND VGND VPWR VPWR sky130_fd_sc_hd__decap_3
XFILLER_109_541 VGND VGND VPWR VPWR sky130_fd_sc_hd__decap_3
XFILLER_7_635 VGND VGND VPWR VPWR sky130_fd_sc_hd__decap_3
Xwire555 _4619_/Y VGND VGND VPWR VPWR wire555/X sky130_fd_sc_hd__clkdlybuf4s25_1
XFILLER_109_585 VGND VGND VPWR VPWR sky130_fd_sc_hd__decap_3
XFILLER_7_668 VGND VGND VPWR VPWR sky130_fd_sc_hd__decap_3
XFILLER_7_679 VGND VGND VPWR VPWR sky130_fd_sc_hd__decap_3
XFILLER_88_85 VGND VGND VPWR VPWR sky130_fd_sc_hd__decap_3
XFILLER_78_631 VGND VGND VPWR VPWR sky130_fd_sc_hd__decap_3
XFILLER_19_6 VGND VGND VPWR VPWR sky130_fd_sc_hd__decap_3
XFILLER_65_303 VGND VGND VPWR VPWR sky130_fd_sc_hd__decap_3
XFILLER_78_675 VGND VGND VPWR VPWR sky130_fd_sc_hd__decap_3
XFILLER_93_612 VGND VGND VPWR VPWR sky130_fd_sc_hd__decap_3
XFILLER_93_623 VGND VGND VPWR VPWR sky130_fd_sc_hd__decap_3
XFILLER_92_133 VGND VGND VPWR VPWR sky130_fd_sc_hd__decap_3
XFILLER_93_656 VGND VGND VPWR VPWR sky130_fd_sc_hd__decap_3
XFILLER_18_230 VGND VGND VPWR VPWR sky130_fd_sc_hd__fill_2
XFILLER_18_241 VGND VGND VPWR VPWR sky130_fd_sc_hd__decap_3
XFILLER_92_144 VGND VGND VPWR VPWR sky130_fd_sc_hd__fill_2
XFILLER_80_317 VGND VGND VPWR VPWR sky130_fd_sc_hd__fill_1
XFILLER_80_339 VGND VGND VPWR VPWR sky130_fd_sc_hd__fill_2
XFILLER_92_188 VGND VGND VPWR VPWR sky130_fd_sc_hd__decap_3
X_4820_ _5156_/S _5634_/B VGND VGND VPWR VPWR _5010_/A sky130_fd_sc_hd__nand2_2
XTAP_TAPCELL_ROW_16_442 VGND VPWR sky130_fd_sc_hd__tapvpwrvgnd_1
XFILLER_33_255 VGND VGND VPWR VPWR sky130_fd_sc_hd__decap_3
XFILLER_61_564 VGND VGND VPWR VPWR sky130_fd_sc_hd__decap_3
XFILLER_61_597 VGND VGND VPWR VPWR sky130_fd_sc_hd__decap_3
XTAP_TAPCELL_ROW_44_784 VGND VPWR sky130_fd_sc_hd__tapvpwrvgnd_1
XFILLER_14_480 VGND VGND VPWR VPWR sky130_fd_sc_hd__decap_3
XFILLER_33_299 VGND VGND VPWR VPWR sky130_fd_sc_hd__decap_3
X_4751_ _4751_/A _4751_/B VGND VGND VPWR VPWR _4751_/Y sky130_fd_sc_hd__nand2_2
X_4682_ _4928_/B _4682_/B _4960_/B VGND VGND VPWR VPWR _4943_/A sky130_fd_sc_hd__and3b_2
X_3702_ hold971/X _4832_/A _3701_/X VGND VGND VPWR VPWR _7401_/D sky130_fd_sc_hd__o21a_2
X_6421_ _6652_/A VGND VGND VPWR VPWR _6421_/Y sky130_fd_sc_hd__inv_2
X_3633_ _3636_/A _3609_/B _3635_/B _3630_/A VGND VGND VPWR VPWR _3633_/Y sky130_fd_sc_hd__a22oi_2
XFILLER_115_500 VGND VGND VPWR VPWR sky130_fd_sc_hd__decap_3
XFILLER_108_18 VGND VGND VPWR VPWR sky130_fd_sc_hd__decap_3
XFILLER_108_29 VGND VGND VPWR VPWR sky130_fd_sc_hd__decap_3
XFILLER_115_511 VGND VGND VPWR VPWR sky130_fd_sc_hd__decap_3
XFILLER_6_690 VGND VGND VPWR VPWR sky130_fd_sc_hd__fill_1
X_6352_ _6673_/A VGND VGND VPWR VPWR _6352_/Y sky130_fd_sc_hd__inv_2
X_3564_ _5118_/A _5362_/C VGND VGND VPWR VPWR _3564_/X sky130_fd_sc_hd__and2_2
XFILLER_115_544 VGND VGND VPWR VPWR sky130_fd_sc_hd__decap_3
X_6283_ _6462_/A VGND VGND VPWR VPWR _6283_/Y sky130_fd_sc_hd__inv_2
X_3495_ _7028_/Q _3562_/A _3494_/X VGND VGND VPWR VPWR _3495_/X sky130_fd_sc_hd__a21o_2
XFILLER_115_588 VGND VGND VPWR VPWR sky130_fd_sc_hd__decap_3
XFILLER_69_620 VGND VGND VPWR VPWR sky130_fd_sc_hd__decap_3
X_5234_ _5234_/A0 _4734_/X _5256_/S VGND VGND VPWR VPWR _7213_/D sky130_fd_sc_hd__mux2_2
XFILLER_102_238 VGND VGND VPWR VPWR sky130_fd_sc_hd__decap_3
XFILLER_69_653 VGND VGND VPWR VPWR sky130_fd_sc_hd__decap_3
X_5165_ _5165_/A _5177_/B VGND VGND VPWR VPWR _7245_/D sky130_fd_sc_hd__and2_2
XTAP_TAPCELL_ROW_110_1566 VGND VPWR sky130_fd_sc_hd__tapvpwrvgnd_1
XFILLER_56_303 VGND VGND VPWR VPWR sky130_fd_sc_hd__decap_3
XFILLER_68_141 VGND VGND VPWR VPWR sky130_fd_sc_hd__fill_2
XFILLER_84_601 VGND VGND VPWR VPWR sky130_fd_sc_hd__decap_3
XFILLER_96_450 VGND VGND VPWR VPWR sky130_fd_sc_hd__decap_3
XFILLER_96_461 VGND VGND VPWR VPWR sky130_fd_sc_hd__decap_3
X_4116_ _7076_/Q _4265_/B VGND VGND VPWR VPWR _4117_/C sky130_fd_sc_hd__or2_2
XTAP_TAPCELL_ROW_110_1577 VGND VPWR sky130_fd_sc_hd__tapvpwrvgnd_1
XFILLER_56_347 VGND VGND VPWR VPWR sky130_fd_sc_hd__decap_3
XFILLER_68_174 VGND VGND VPWR VPWR sky130_fd_sc_hd__decap_3
XFILLER_83_122 VGND VGND VPWR VPWR sky130_fd_sc_hd__fill_2
XFILLER_84_634 VGND VGND VPWR VPWR sky130_fd_sc_hd__decap_3
XFILLER_84_645 VGND VGND VPWR VPWR sky130_fd_sc_hd__decap_3
XFILLER_96_483 VGND VGND VPWR VPWR sky130_fd_sc_hd__decap_3
XFILLER_96_494 VGND VGND VPWR VPWR sky130_fd_sc_hd__decap_3
XFILLER_37_550 VGND VGND VPWR VPWR sky130_fd_sc_hd__decap_3
XFILLER_37_561 VGND VGND VPWR VPWR sky130_fd_sc_hd__decap_3
XFILLER_84_678 VGND VGND VPWR VPWR sky130_fd_sc_hd__decap_3
X_4047_ _7245_/Q _4433_/B _4437_/A2 _7027_/Q _4046_/X VGND VGND VPWR VPWR _4047_/X
+ sky130_fd_sc_hd__a221o_2
XFILLER_24_200 VGND VGND VPWR VPWR sky130_fd_sc_hd__decap_3
XFILLER_37_594 VGND VGND VPWR VPWR sky130_fd_sc_hd__decap_3
XFILLER_64_380 VGND VGND VPWR VPWR sky130_fd_sc_hd__fill_1
XFILLER_71_328 VGND VGND VPWR VPWR sky130_fd_sc_hd__fill_1
XFILLER_24_222 VGND VGND VPWR VPWR sky130_fd_sc_hd__decap_3
XTAP_TAPCELL_ROW_65_1034 VGND VPWR sky130_fd_sc_hd__tapvpwrvgnd_1
XFILLER_12_417 VGND VGND VPWR VPWR sky130_fd_sc_hd__decap_3
XFILLER_24_277 VGND VGND VPWR VPWR sky130_fd_sc_hd__decap_3
XFILLER_52_586 VGND VGND VPWR VPWR sky130_fd_sc_hd__fill_2
X_4949_ _4967_/A _4967_/B VGND VGND VPWR VPWR _4949_/Y sky130_fd_sc_hd__nand2_2
XFILLER_20_461 VGND VGND VPWR VPWR sky130_fd_sc_hd__fill_2
X_6619_ _6620_/A VGND VGND VPWR VPWR _6619_/Y sky130_fd_sc_hd__inv_2
XFILLER_4_616 VGND VGND VPWR VPWR sky130_fd_sc_hd__decap_3
XFILLER_106_522 VGND VGND VPWR VPWR sky130_fd_sc_hd__decap_3
XFILLER_106_533 VGND VGND VPWR VPWR sky130_fd_sc_hd__decap_3
XFILLER_106_566 VGND VGND VPWR VPWR sky130_fd_sc_hd__decap_3
XFILLER_3_148 VGND VGND VPWR VPWR sky130_fd_sc_hd__decap_3
XTAP_TAPCELL_ROW_76_1163 VGND VPWR sky130_fd_sc_hd__tapvpwrvgnd_1
XFILLER_79_428 VGND VGND VPWR VPWR sky130_fd_sc_hd__fill_1
XFILLER_75_612 VGND VGND VPWR VPWR sky130_fd_sc_hd__decap_3
XFILLER_114_50 VGND VGND VPWR VPWR sky130_fd_sc_hd__decap_3
XFILLER_47_314 VGND VGND VPWR VPWR sky130_fd_sc_hd__decap_3
XFILLER_74_100 VGND VGND VPWR VPWR sky130_fd_sc_hd__decap_3
XFILLER_75_623 VGND VGND VPWR VPWR sky130_fd_sc_hd__decap_3
XFILLER_75_656 VGND VGND VPWR VPWR sky130_fd_sc_hd__decap_3
XFILLER_114_83 VGND VGND VPWR VPWR sky130_fd_sc_hd__fill_1
XFILLER_114_94 VGND VGND VPWR VPWR sky130_fd_sc_hd__decap_3
XFILLER_74_133 VGND VGND VPWR VPWR sky130_fd_sc_hd__decap_3
XFILLER_74_32 VGND VGND VPWR VPWR sky130_fd_sc_hd__fill_1
XFILLER_90_604 VGND VGND VPWR VPWR sky130_fd_sc_hd__decap_3
XFILLER_15_200 VGND VGND VPWR VPWR sky130_fd_sc_hd__decap_3
XFILLER_28_572 VGND VGND VPWR VPWR sky130_fd_sc_hd__decap_3
XFILLER_43_520 VGND VGND VPWR VPWR sky130_fd_sc_hd__fill_1
XFILLER_74_177 VGND VGND VPWR VPWR sky130_fd_sc_hd__decap_3
XFILLER_90_637 VGND VGND VPWR VPWR sky130_fd_sc_hd__decap_3
XFILLER_90_648 VGND VGND VPWR VPWR sky130_fd_sc_hd__decap_3
XFILLER_15_222 VGND VGND VPWR VPWR sky130_fd_sc_hd__fill_2
XTAP_TAPCELL_ROW_87_1292 VGND VPWR sky130_fd_sc_hd__tapvpwrvgnd_1
XFILLER_15_277 VGND VGND VPWR VPWR sky130_fd_sc_hd__decap_3
XFILLER_43_564 VGND VGND VPWR VPWR sky130_fd_sc_hd__decap_3
XFILLER_43_597 VGND VGND VPWR VPWR sky130_fd_sc_hd__decap_3
XTAP_TAPCELL_ROW_13_412 VGND VPWR sky130_fd_sc_hd__tapvpwrvgnd_1
XTAP_TAPCELL_ROW_41_743 VGND VPWR sky130_fd_sc_hd__tapvpwrvgnd_1
XFILLER_23_91 VGND VGND VPWR VPWR sky130_fd_sc_hd__decap_3
XFILLER_7_421 VGND VGND VPWR VPWR sky130_fd_sc_hd__fill_2
XFILLER_7_465 VGND VGND VPWR VPWR sky130_fd_sc_hd__decap_3
XFILLER_109_371 VGND VGND VPWR VPWR sky130_fd_sc_hd__decap_3
XFILLER_109_393 VGND VGND VPWR VPWR sky130_fd_sc_hd__decap_3
XFILLER_112_525 VGND VGND VPWR VPWR sky130_fd_sc_hd__decap_3
XFILLER_3_671 VGND VGND VPWR VPWR sky130_fd_sc_hd__fill_1
XFILLER_3_682 VGND VGND VPWR VPWR sky130_fd_sc_hd__decap_3
XFILLER_97_225 VGND VGND VPWR VPWR sky130_fd_sc_hd__fill_2
XFILLER_112_536 VGND VGND VPWR VPWR sky130_fd_sc_hd__decap_3
XFILLER_112_569 VGND VGND VPWR VPWR sky130_fd_sc_hd__decap_3
XFILLER_2_170 VGND VGND VPWR VPWR sky130_fd_sc_hd__decap_3
XFILLER_66_601 VGND VGND VPWR VPWR sky130_fd_sc_hd__decap_3
XFILLER_65_111 VGND VGND VPWR VPWR sky130_fd_sc_hd__fill_1
XFILLER_66_634 VGND VGND VPWR VPWR sky130_fd_sc_hd__decap_3
XFILLER_66_645 VGND VGND VPWR VPWR sky130_fd_sc_hd__decap_3
XFILLER_78_483 VGND VGND VPWR VPWR sky130_fd_sc_hd__fill_2
XFILLER_93_431 VGND VGND VPWR VPWR sky130_fd_sc_hd__decap_3
XTAP_TAPCELL_ROW_49_843 VGND VPWR sky130_fd_sc_hd__tapvpwrvgnd_1
XFILLER_66_678 VGND VGND VPWR VPWR sky130_fd_sc_hd__decap_3
XFILLER_81_615 VGND VGND VPWR VPWR sky130_fd_sc_hd__fill_1
X_6970_ _6970_/CLK _6970_/D VGND VGND VPWR VPWR _6970_/Q sky130_fd_sc_hd__dfxtp_2
XFILLER_19_561 VGND VGND VPWR VPWR sky130_fd_sc_hd__decap_3
XFILLER_53_317 VGND VGND VPWR VPWR sky130_fd_sc_hd__fill_2
XFILLER_81_626 VGND VGND VPWR VPWR sky130_fd_sc_hd__decap_3
XFILLER_93_497 VGND VGND VPWR VPWR sky130_fd_sc_hd__decap_3
XFILLER_19_594 VGND VGND VPWR VPWR sky130_fd_sc_hd__decap_3
XFILLER_34_553 VGND VGND VPWR VPWR sky130_fd_sc_hd__decap_3
XFILLER_80_136 VGND VGND VPWR VPWR sky130_fd_sc_hd__decap_3
XFILLER_80_147 VGND VGND VPWR VPWR sky130_fd_sc_hd__decap_3
XFILLER_81_659 VGND VGND VPWR VPWR sky130_fd_sc_hd__decap_3
XFILLER_34_586 VGND VGND VPWR VPWR sky130_fd_sc_hd__fill_2
XFILLER_21_225 VGND VGND VPWR VPWR sky130_fd_sc_hd__decap_3
X_4803_ _7003_/Q _4802_/X _4677_/B _3403_/A VGND VGND VPWR VPWR _4804_/B sky130_fd_sc_hd__o211ai_2
XFILLER_21_258 VGND VGND VPWR VPWR sky130_fd_sc_hd__decap_3
X_4734_ _4726_/X _4729_/Y _7007_/D _5040_/S VGND VGND VPWR VPWR _4734_/X sky130_fd_sc_hd__o22a_2
XFILLER_107_319 VGND VGND VPWR VPWR sky130_fd_sc_hd__decap_3
X_4665_ _7005_/Q _5622_/B VGND VGND VPWR VPWR _4665_/X sky130_fd_sc_hd__or2_2
X_7384_ _7398_/CLK _7384_/D _6664_/Y VGND VGND VPWR VPWR _7384_/Q sky130_fd_sc_hd__dfrtp_2
Xhold900 _7104_/Q VGND VGND VPWR VPWR _7104_/D sky130_fd_sc_hd__dlygate4sd3_1
Xhold911 _6697_/Q VGND VGND VPWR VPWR hold911/X sky130_fd_sc_hd__dlygate4sd3_1
Xhold922 _6709_/Q VGND VGND VPWR VPWR hold922/X sky130_fd_sc_hd__dlygate4sd3_1
X_6404_ _6628_/A VGND VGND VPWR VPWR _6404_/Y sky130_fd_sc_hd__inv_2
X_3616_ _4614_/C _3616_/B VGND VGND VPWR VPWR _3616_/Y sky130_fd_sc_hd__nand2_2
Xhold955 _7024_/Q VGND VGND VPWR VPWR _5607_/A sky130_fd_sc_hd__dlygate4sd3_1
Xhold944 _7042_/Q VGND VGND VPWR VPWR hold944/X sky130_fd_sc_hd__dlygate4sd3_1
Xhold933 _6695_/Q VGND VGND VPWR VPWR hold933/X sky130_fd_sc_hd__dlygate4sd3_1
X_6335_ _6628_/A VGND VGND VPWR VPWR _6335_/Y sky130_fd_sc_hd__inv_2
X_3547_ _3547_/A _3547_/B VGND VGND VPWR VPWR _3547_/Y sky130_fd_sc_hd__nand2_2
XFILLER_103_514 VGND VGND VPWR VPWR sky130_fd_sc_hd__decap_3
XFILLER_88_214 VGND VGND VPWR VPWR sky130_fd_sc_hd__decap_3
Xhold988 _7279_/Q VGND VGND VPWR VPWR hold988/X sky130_fd_sc_hd__dlygate4sd3_1
Xhold977 _7320_/Q VGND VGND VPWR VPWR hold977/X sky130_fd_sc_hd__dlygate4sd3_1
Xhold966 _7023_/Q VGND VGND VPWR VPWR _5609_/A sky130_fd_sc_hd__dlygate4sd3_1
XFILLER_103_547 VGND VGND VPWR VPWR sky130_fd_sc_hd__decap_3
XFILLER_115_396 VGND VGND VPWR VPWR sky130_fd_sc_hd__decap_3
Xhold999 _7244_/Q VGND VGND VPWR VPWR _5167_/A sky130_fd_sc_hd__dlygate4sd3_1
X_6266_ _6673_/A VGND VGND VPWR VPWR _6266_/Y sky130_fd_sc_hd__inv_2
X_3478_ _7216_/Q _4331_/A2 _4534_/S _7029_/Q _3477_/X VGND VGND VPWR VPWR _3478_/X
+ sky130_fd_sc_hd__a221o_2
XFILLER_57_612 VGND VGND VPWR VPWR sky130_fd_sc_hd__decap_3
X_5217_ _5217_/A _5225_/B VGND VGND VPWR VPWR _7220_/D sky130_fd_sc_hd__and2_2
XFILLER_111_591 VGND VGND VPWR VPWR sky130_fd_sc_hd__decap_3
XFILLER_57_623 VGND VGND VPWR VPWR sky130_fd_sc_hd__decap_3
XFILLER_84_431 VGND VGND VPWR VPWR sky130_fd_sc_hd__decap_3
XFILLER_96_280 VGND VGND VPWR VPWR sky130_fd_sc_hd__fill_1
XFILLER_96_291 VGND VGND VPWR VPWR sky130_fd_sc_hd__decap_3
X_5148_ _5144_/A _5071_/A _3521_/Y _3540_/X VGND VGND VPWR VPWR _5148_/X sky130_fd_sc_hd__a211o_2
XFILLER_29_358 VGND VGND VPWR VPWR sky130_fd_sc_hd__decap_3
XFILLER_57_656 VGND VGND VPWR VPWR sky130_fd_sc_hd__decap_3
XFILLER_72_604 VGND VGND VPWR VPWR sky130_fd_sc_hd__decap_3
X_5079_ _5156_/S _6987_/D _5078_/X VGND VGND VPWR VPWR _5079_/X sky130_fd_sc_hd__o21a_2
XFILLER_72_637 VGND VGND VPWR VPWR sky130_fd_sc_hd__decap_3
XFILLER_72_648 VGND VGND VPWR VPWR sky130_fd_sc_hd__decap_3
XFILLER_37_380 VGND VGND VPWR VPWR sky130_fd_sc_hd__fill_2
XFILLER_44_24 VGND VGND VPWR VPWR sky130_fd_sc_hd__decap_3
XFILLER_71_125 VGND VGND VPWR VPWR sky130_fd_sc_hd__decap_3
XFILLER_12_203 VGND VGND VPWR VPWR sky130_fd_sc_hd__fill_2
XFILLER_25_564 VGND VGND VPWR VPWR sky130_fd_sc_hd__decap_3
XFILLER_52_361 VGND VGND VPWR VPWR sky130_fd_sc_hd__decap_3
XFILLER_71_169 VGND VGND VPWR VPWR sky130_fd_sc_hd__decap_3
XFILLER_12_225 VGND VGND VPWR VPWR sky130_fd_sc_hd__decap_3
XFILLER_25_597 VGND VGND VPWR VPWR sky130_fd_sc_hd__decap_3
XFILLER_80_681 VGND VGND VPWR VPWR sky130_fd_sc_hd__decap_3
XFILLER_100_41 VGND VGND VPWR VPWR sky130_fd_sc_hd__fill_1
XFILLER_40_578 VGND VGND VPWR VPWR sky130_fd_sc_hd__decap_3
XFILLER_100_74 VGND VGND VPWR VPWR sky130_fd_sc_hd__fill_2
XFILLER_100_85 VGND VGND VPWR VPWR sky130_fd_sc_hd__decap_3
XFILLER_40_589 VGND VGND VPWR VPWR sky130_fd_sc_hd__decap_3
XFILLER_20_280 VGND VGND VPWR VPWR sky130_fd_sc_hd__fill_2
XFILLER_109_50 VGND VGND VPWR VPWR sky130_fd_sc_hd__decap_3
XFILLER_5_18 VGND VGND VPWR VPWR sky130_fd_sc_hd__decap_3
XFILLER_79_225 VGND VGND VPWR VPWR sky130_fd_sc_hd__decap_3
XFILLER_0_663 VGND VGND VPWR VPWR sky130_fd_sc_hd__fill_1
XFILLER_48_601 VGND VGND VPWR VPWR sky130_fd_sc_hd__decap_3
XFILLER_79_269 VGND VGND VPWR VPWR sky130_fd_sc_hd__decap_3
XFILLER_0_685 VGND VGND VPWR VPWR sky130_fd_sc_hd__decap_3
XFILLER_47_111 VGND VGND VPWR VPWR sky130_fd_sc_hd__fill_1
XFILLER_48_634 VGND VGND VPWR VPWR sky130_fd_sc_hd__decap_3
XFILLER_48_645 VGND VGND VPWR VPWR sky130_fd_sc_hd__decap_3
XTAP_TAPCELL_ROW_89_1321 VGND VPWR sky130_fd_sc_hd__tapvpwrvgnd_1
XFILLER_48_678 VGND VGND VPWR VPWR sky130_fd_sc_hd__decap_3
XFILLER_75_442 VGND VGND VPWR VPWR sky130_fd_sc_hd__decap_3
XFILLER_47_166 VGND VGND VPWR VPWR sky130_fd_sc_hd__fill_2
XFILLER_63_615 VGND VGND VPWR VPWR sky130_fd_sc_hd__fill_1
XFILLER_63_626 VGND VGND VPWR VPWR sky130_fd_sc_hd__decap_3
XFILLER_85_97 VGND VGND VPWR VPWR sky130_fd_sc_hd__decap_3
XFILLER_90_401 VGND VGND VPWR VPWR sky130_fd_sc_hd__decap_3
XTAP_TAPCELL_ROW_46_802 VGND VPWR sky130_fd_sc_hd__tapvpwrvgnd_1
XFILLER_16_520 VGND VGND VPWR VPWR sky130_fd_sc_hd__decap_3
XFILLER_16_542 VGND VGND VPWR VPWR sky130_fd_sc_hd__decap_3
XFILLER_63_659 VGND VGND VPWR VPWR sky130_fd_sc_hd__decap_3
XFILLER_90_434 VGND VGND VPWR VPWR sky130_fd_sc_hd__decap_3
XFILLER_16_575 VGND VGND VPWR VPWR sky130_fd_sc_hd__decap_3
XFILLER_31_501 VGND VGND VPWR VPWR sky130_fd_sc_hd__decap_3
XFILLER_50_309 VGND VGND VPWR VPWR sky130_fd_sc_hd__decap_3
XFILLER_90_467 VGND VGND VPWR VPWR sky130_fd_sc_hd__fill_1
XFILLER_70_180 VGND VGND VPWR VPWR sky130_fd_sc_hd__decap_3
XFILLER_31_567 VGND VGND VPWR VPWR sky130_fd_sc_hd__decap_3
XFILLER_11_291 VGND VGND VPWR VPWR sky130_fd_sc_hd__decap_3
XFILLER_116_116 VGND VGND VPWR VPWR sky130_fd_sc_hd__fill_1
XFILLER_7_284 VGND VGND VPWR VPWR sky130_fd_sc_hd__fill_1
X_4450_ _4451_/A _4451_/B VGND VGND VPWR VPWR _4452_/A sky130_fd_sc_hd__and2_2
XFILLER_116_149 VGND VGND VPWR VPWR sky130_fd_sc_hd__decap_3
X_4381_ _4381_/A _4381_/B VGND VGND VPWR VPWR _4967_/B sky130_fd_sc_hd__nand2_2
X_3401_ _4467_/A _3519_/B _5294_/A _3330_/Y VGND VGND VPWR VPWR _3401_/X sky130_fd_sc_hd__a31o_4
X_3332_ _4467_/A _3332_/B VGND VGND VPWR VPWR _3341_/A sky130_fd_sc_hd__nand2_2
XFILLER_98_501 VGND VGND VPWR VPWR sky130_fd_sc_hd__decap_3
XFILLER_3_490 VGND VGND VPWR VPWR sky130_fd_sc_hd__decap_3
XFILLER_98_545 VGND VGND VPWR VPWR sky130_fd_sc_hd__decap_3
XFILLER_85_206 VGND VGND VPWR VPWR sky130_fd_sc_hd__fill_1
XFILLER_98_589 VGND VGND VPWR VPWR sky130_fd_sc_hd__decap_3
XFILLER_98_578 VGND VGND VPWR VPWR sky130_fd_sc_hd__decap_3
XFILLER_100_528 VGND VGND VPWR VPWR sky130_fd_sc_hd__decap_3
XFILLER_100_539 VGND VGND VPWR VPWR sky130_fd_sc_hd__decap_3
XFILLER_112_388 VGND VGND VPWR VPWR sky130_fd_sc_hd__decap_3
XFILLER_39_612 VGND VGND VPWR VPWR sky130_fd_sc_hd__decap_3
XFILLER_39_623 VGND VGND VPWR VPWR sky130_fd_sc_hd__decap_3
X_5002_ _5003_/A _5003_/B _3548_/X VGND VGND VPWR VPWR _5002_/Y sky130_fd_sc_hd__a21oi_2
XFILLER_39_656 VGND VGND VPWR VPWR sky130_fd_sc_hd__decap_3
XFILLER_54_604 VGND VGND VPWR VPWR sky130_fd_sc_hd__decap_3
XFILLER_78_291 VGND VGND VPWR VPWR sky130_fd_sc_hd__decap_3
XFILLER_26_306 VGND VGND VPWR VPWR sky130_fd_sc_hd__fill_2
XFILLER_54_637 VGND VGND VPWR VPWR sky130_fd_sc_hd__decap_3
XFILLER_81_423 VGND VGND VPWR VPWR sky130_fd_sc_hd__fill_2
XFILLER_54_648 VGND VGND VPWR VPWR sky130_fd_sc_hd__decap_3
XFILLER_81_434 VGND VGND VPWR VPWR sky130_fd_sc_hd__decap_3
X_6953_ _6959_/CLK _6953_/D VGND VGND VPWR VPWR _6953_/Q sky130_fd_sc_hd__dfxtp_2
XFILLER_41_309 VGND VGND VPWR VPWR sky130_fd_sc_hd__decap_3
Xclkbuf_3_5__f_clk clkbuf_0_clk/X VGND VGND VPWR VPWR clkload3/A sky130_fd_sc_hd__clkbuf_16
X_6884_ _7398_/CLK _6884_/D VGND VGND VPWR VPWR _6884_/Q sky130_fd_sc_hd__dfxtp_2
XFILLER_62_681 VGND VGND VPWR VPWR sky130_fd_sc_hd__decap_3
XFILLER_14_49 VGND VGND VPWR VPWR sky130_fd_sc_hd__decap_3
XFILLER_22_556 VGND VGND VPWR VPWR sky130_fd_sc_hd__decap_3
XFILLER_22_589 VGND VGND VPWR VPWR sky130_fd_sc_hd__decap_3
X_5697_ _7354_/Q hold923/X _5703_/S VGND VGND VPWR VPWR _6698_/D sky130_fd_sc_hd__mux2_2
XFILLER_108_628 VGND VGND VPWR VPWR sky130_fd_sc_hd__decap_3
X_4648_ _4648_/A VGND VGND VPWR VPWR _4648_/Y sky130_fd_sc_hd__inv_2
Xhold730 _6976_/Q VGND VGND VPWR VPWR _6976_/D sky130_fd_sc_hd__dlygate4sd3_1
XFILLER_89_523 VGND VGND VPWR VPWR sky130_fd_sc_hd__decap_3
X_7367_ _7405_/CLK _7367_/D _6647_/Y VGND VGND VPWR VPWR _7367_/Q sky130_fd_sc_hd__dfrtp_2
Xhold741 _6895_/Q VGND VGND VPWR VPWR _6895_/D sky130_fd_sc_hd__dlygate4sd3_1
Xhold752 _6958_/Q VGND VGND VPWR VPWR _6958_/D sky130_fd_sc_hd__dlygate4sd3_1
Xhold763 _6901_/Q VGND VGND VPWR VPWR _6901_/D sky130_fd_sc_hd__dlygate4sd3_1
X_4579_ _7291_/Q _4595_/B VGND VGND VPWR VPWR _7291_/D sky130_fd_sc_hd__and2_2
XTAP_TAPCELL_ROW_73_1122 VGND VPWR sky130_fd_sc_hd__tapvpwrvgnd_1
XFILLER_103_322 VGND VGND VPWR VPWR sky130_fd_sc_hd__fill_1
XFILLER_89_556 VGND VGND VPWR VPWR sky130_fd_sc_hd__decap_3
X_7298_ _7332_/CLK _7298_/D _6578_/Y VGND VGND VPWR VPWR _7298_/Q sky130_fd_sc_hd__dfrtp_2
Xhold774 _6925_/Q VGND VGND VPWR VPWR _6925_/D sky130_fd_sc_hd__dlygate4sd3_1
Xhold785 _6773_/Q VGND VGND VPWR VPWR _6773_/D sky130_fd_sc_hd__dlygate4sd3_1
Xhold796 _6886_/Q VGND VGND VPWR VPWR _6886_/D sky130_fd_sc_hd__dlygate4sd3_1
X_6318_ _6673_/A VGND VGND VPWR VPWR _6318_/Y sky130_fd_sc_hd__inv_2
XTAP_TAPCELL_ROW_73_1133 VGND VPWR sky130_fd_sc_hd__tapvpwrvgnd_1
XFILLER_103_366 VGND VGND VPWR VPWR sky130_fd_sc_hd__decap_3
XFILLER_76_206 VGND VGND VPWR VPWR sky130_fd_sc_hd__fill_2
XFILLER_89_567 VGND VGND VPWR VPWR sky130_fd_sc_hd__decap_3
XFILLER_103_399 VGND VGND VPWR VPWR sky130_fd_sc_hd__decap_3
XFILLER_76_239 VGND VGND VPWR VPWR sky130_fd_sc_hd__decap_3
XFILLER_29_122 VGND VGND VPWR VPWR sky130_fd_sc_hd__decap_3
XFILLER_69_291 VGND VGND VPWR VPWR sky130_fd_sc_hd__decap_3
XFILLER_91_209 VGND VGND VPWR VPWR sky130_fd_sc_hd__decap_3
XFILLER_45_615 VGND VGND VPWR VPWR sky130_fd_sc_hd__fill_1
XFILLER_45_626 VGND VGND VPWR VPWR sky130_fd_sc_hd__decap_3
XFILLER_55_12 VGND VGND VPWR VPWR sky130_fd_sc_hd__decap_3
XTAP_TAPCELL_ROW_4_298 VGND VPWR sky130_fd_sc_hd__tapvpwrvgnd_1
XFILLER_45_659 VGND VGND VPWR VPWR sky130_fd_sc_hd__decap_3
XFILLER_55_45 VGND VGND VPWR VPWR sky130_fd_sc_hd__decap_3
XFILLER_84_283 VGND VGND VPWR VPWR sky130_fd_sc_hd__fill_1
XFILLER_25_361 VGND VGND VPWR VPWR sky130_fd_sc_hd__fill_2
XFILLER_32_309 VGND VGND VPWR VPWR sky130_fd_sc_hd__decap_3
XFILLER_55_89 VGND VGND VPWR VPWR sky130_fd_sc_hd__decap_3
XFILLER_60_607 VGND VGND VPWR VPWR sky130_fd_sc_hd__decap_3
XFILLER_111_51 VGND VGND VPWR VPWR sky130_fd_sc_hd__decap_3
XFILLER_13_534 VGND VGND VPWR VPWR sky130_fd_sc_hd__decap_3
XFILLER_71_11 VGND VGND VPWR VPWR sky130_fd_sc_hd__decap_3
XTAP_TAPCELL_ROW_84_1262 VGND VPWR sky130_fd_sc_hd__tapvpwrvgnd_1
XFILLER_13_567 VGND VGND VPWR VPWR sky130_fd_sc_hd__decap_3
XFILLER_40_331 VGND VGND VPWR VPWR sky130_fd_sc_hd__decap_3
XFILLER_40_353 VGND VGND VPWR VPWR sky130_fd_sc_hd__decap_3
XFILLER_71_55 VGND VGND VPWR VPWR sky130_fd_sc_hd__fill_1
XFILLER_9_505 VGND VGND VPWR VPWR sky130_fd_sc_hd__decap_3
XTAP_TAPCELL_ROW_51_860 VGND VPWR sky130_fd_sc_hd__tapvpwrvgnd_1
XFILLER_9_538 VGND VGND VPWR VPWR sky130_fd_sc_hd__decap_3
XFILLER_107_650 VGND VGND VPWR VPWR sky130_fd_sc_hd__decap_3
XFILLER_4_232 VGND VGND VPWR VPWR sky130_fd_sc_hd__decap_3
XTAP_TAPCELL_ROW_95_1391 VGND VPWR sky130_fd_sc_hd__tapvpwrvgnd_1
XFILLER_106_171 VGND VGND VPWR VPWR sky130_fd_sc_hd__decap_3
XFILLER_0_460 VGND VGND VPWR VPWR sky130_fd_sc_hd__decap_3
XFILLER_67_217 VGND VGND VPWR VPWR sky130_fd_sc_hd__decap_3
XFILLER_95_526 VGND VGND VPWR VPWR sky130_fd_sc_hd__decap_3
XFILLER_96_96 VGND VGND VPWR VPWR sky130_fd_sc_hd__decap_3
XFILLER_95_559 VGND VGND VPWR VPWR sky130_fd_sc_hd__fill_1
XFILLER_36_604 VGND VGND VPWR VPWR sky130_fd_sc_hd__decap_3
XFILLER_36_637 VGND VGND VPWR VPWR sky130_fd_sc_hd__decap_3
XFILLER_75_261 VGND VGND VPWR VPWR sky130_fd_sc_hd__decap_3
XFILLER_75_272 VGND VGND VPWR VPWR sky130_fd_sc_hd__decap_3
XTAP_TAPCELL_ROW_59_960 VGND VPWR sky130_fd_sc_hd__tapvpwrvgnd_1
XFILLER_36_648 VGND VGND VPWR VPWR sky130_fd_sc_hd__decap_3
XFILLER_63_434 VGND VGND VPWR VPWR sky130_fd_sc_hd__decap_3
Xplace401 _4300_/B VGND VGND VPWR VPWR _4532_/S sky130_fd_sc_hd__buf_2
Xplace412 _4346_/B1 VGND VGND VPWR VPWR _4261_/A2 sky130_fd_sc_hd__buf_2
XFILLER_51_629 VGND VGND VPWR VPWR sky130_fd_sc_hd__decap_3
XFILLER_63_478 VGND VGND VPWR VPWR sky130_fd_sc_hd__decap_3
Xplace423 _3968_/S VGND VGND VPWR VPWR _3964_/S sky130_fd_sc_hd__buf_2
Xplace434 _5156_/S VGND VGND VPWR VPWR _5040_/S sky130_fd_sc_hd__buf_2
Xplace445 _4284_/A2 VGND VGND VPWR VPWR _4331_/A2 sky130_fd_sc_hd__buf_2
Xplace456 _3331_/B VGND VGND VPWR VPWR _3403_/A sky130_fd_sc_hd__buf_2
XFILLER_16_361 VGND VGND VPWR VPWR sky130_fd_sc_hd__decap_3
XFILLER_44_681 VGND VGND VPWR VPWR sky130_fd_sc_hd__decap_3
XFILLER_50_117 VGND VGND VPWR VPWR sky130_fd_sc_hd__decap_3
XFILLER_31_353 VGND VGND VPWR VPWR sky130_fd_sc_hd__decap_3
X_3881_ _6724_/Q _3888_/A2 _3888_/B1 _6719_/Q VGND VGND VPWR VPWR _3881_/X sky130_fd_sc_hd__a22o_2
XFILLER_8_560 VGND VGND VPWR VPWR sky130_fd_sc_hd__decap_3
XFILLER_105_609 VGND VGND VPWR VPWR sky130_fd_sc_hd__decap_3
X_7221_ _7349_/CLK _7221_/D _6501_/Y VGND VGND VPWR VPWR _7221_/Q sky130_fd_sc_hd__dfrtp_2
XFILLER_104_108 VGND VGND VPWR VPWR sky130_fd_sc_hd__decap_3
X_4433_ _7239_/Q _4433_/B VGND VGND VPWR VPWR _4433_/X sky130_fd_sc_hd__and2_2
XFILLER_113_620 VGND VGND VPWR VPWR sky130_fd_sc_hd__decap_3
XFILLER_116_18 VGND VGND VPWR VPWR sky130_fd_sc_hd__decap_3
X_7152_ _7344_/CLK _7152_/D _6432_/Y VGND VGND VPWR VPWR _7152_/Q sky130_fd_sc_hd__dfrtp_2
X_4364_ _4364_/A _4364_/B VGND VGND VPWR VPWR _4364_/Y sky130_fd_sc_hd__nor2_2
XFILLER_98_320 VGND VGND VPWR VPWR sky130_fd_sc_hd__decap_3
XFILLER_113_653 VGND VGND VPWR VPWR sky130_fd_sc_hd__decap_3
X_7083_ _7403_/CLK _7083_/D _6363_/Y VGND VGND VPWR VPWR _7083_/Q sky130_fd_sc_hd__dfrtp_2
X_4295_ _3607_/B _4295_/B VGND VGND VPWR VPWR _4295_/X sky130_fd_sc_hd__and2b_2
XFILLER_86_548 VGND VGND VPWR VPWR sky130_fd_sc_hd__decap_3
XFILLER_100_336 VGND VGND VPWR VPWR sky130_fd_sc_hd__decap_3
XFILLER_27_615 VGND VGND VPWR VPWR sky130_fd_sc_hd__fill_1
XFILLER_27_626 VGND VGND VPWR VPWR sky130_fd_sc_hd__decap_3
XFILLER_73_209 VGND VGND VPWR VPWR sky130_fd_sc_hd__fill_1
XFILLER_94_581 VGND VGND VPWR VPWR sky130_fd_sc_hd__decap_3
XFILLER_27_659 VGND VGND VPWR VPWR sky130_fd_sc_hd__decap_3
XFILLER_81_231 VGND VGND VPWR VPWR sky130_fd_sc_hd__decap_3
XFILLER_94_592 VGND VGND VPWR VPWR sky130_fd_sc_hd__decap_3
XTAP_TAPCELL_ROW_107_1538 VGND VPWR sky130_fd_sc_hd__tapvpwrvgnd_1
XFILLER_14_309 VGND VGND VPWR VPWR sky130_fd_sc_hd__fill_1
XFILLER_42_607 VGND VGND VPWR VPWR sky130_fd_sc_hd__decap_3
X_6936_ _6954_/CLK _6936_/D VGND VGND VPWR VPWR _6936_/Q sky130_fd_sc_hd__dfxtp_2
XTAP_TAPCELL_ROW_1_268 VGND VPWR sky130_fd_sc_hd__tapvpwrvgnd_1
XFILLER_81_275 VGND VGND VPWR VPWR sky130_fd_sc_hd__decap_3
XTAP_TAPCELL_ROW_37_698 VGND VPWR sky130_fd_sc_hd__tapvpwrvgnd_1
XFILLER_50_640 VGND VGND VPWR VPWR sky130_fd_sc_hd__decap_3
XFILLER_50_651 VGND VGND VPWR VPWR sky130_fd_sc_hd__decap_3
X_6867_ _6943_/CLK _6867_/D VGND VGND VPWR VPWR _6867_/Q sky130_fd_sc_hd__dfxtp_2
XFILLER_10_526 VGND VGND VPWR VPWR sky130_fd_sc_hd__decap_3
XFILLER_50_684 VGND VGND VPWR VPWR sky130_fd_sc_hd__decap_3
X_6798_ _6943_/CLK _6798_/D VGND VGND VPWR VPWR _6798_/Q sky130_fd_sc_hd__dfxtp_2
XFILLER_10_548 VGND VGND VPWR VPWR sky130_fd_sc_hd__decap_3
XFILLER_6_519 VGND VGND VPWR VPWR sky130_fd_sc_hd__decap_3
XFILLER_108_436 VGND VGND VPWR VPWR sky130_fd_sc_hd__decap_3
XFILLER_108_469 VGND VGND VPWR VPWR sky130_fd_sc_hd__decap_3
XFILLER_104_631 VGND VGND VPWR VPWR sky130_fd_sc_hd__decap_3
XFILLER_116_480 VGND VGND VPWR VPWR sky130_fd_sc_hd__decap_3
XTAP_TAPCELL_ROW_9_357 VGND VPWR sky130_fd_sc_hd__tapvpwrvgnd_1
XFILLER_104_675 VGND VGND VPWR VPWR sky130_fd_sc_hd__decap_3
XFILLER_89_353 VGND VGND VPWR VPWR sky130_fd_sc_hd__decap_3
Xhold582 _6864_/Q VGND VGND VPWR VPWR _6864_/D sky130_fd_sc_hd__dlygate4sd3_1
Xhold593 _6833_/Q VGND VGND VPWR VPWR _6833_/D sky130_fd_sc_hd__dlygate4sd3_1
XFILLER_106_62 VGND VGND VPWR VPWR sky130_fd_sc_hd__fill_1
XFILLER_49_228 VGND VGND VPWR VPWR sky130_fd_sc_hd__decap_3
XFILLER_77_537 VGND VGND VPWR VPWR sky130_fd_sc_hd__decap_3
XFILLER_89_386 VGND VGND VPWR VPWR sky130_fd_sc_hd__decap_3
XFILLER_18_604 VGND VGND VPWR VPWR sky130_fd_sc_hd__decap_3
XFILLER_85_570 VGND VGND VPWR VPWR sky130_fd_sc_hd__decap_3
XFILLER_92_529 VGND VGND VPWR VPWR sky130_fd_sc_hd__decap_3
XFILLER_18_637 VGND VGND VPWR VPWR sky130_fd_sc_hd__decap_3
XFILLER_18_648 VGND VGND VPWR VPWR sky130_fd_sc_hd__decap_3
XFILLER_45_478 VGND VGND VPWR VPWR sky130_fd_sc_hd__fill_1
XFILLER_72_242 VGND VGND VPWR VPWR sky130_fd_sc_hd__decap_3
XFILLER_72_253 VGND VGND VPWR VPWR sky130_fd_sc_hd__decap_3
XFILLER_82_32 VGND VGND VPWR VPWR sky130_fd_sc_hd__fill_1
XFILLER_26_681 VGND VGND VPWR VPWR sky130_fd_sc_hd__decap_3
XFILLER_33_629 VGND VGND VPWR VPWR sky130_fd_sc_hd__decap_3
XFILLER_13_320 VGND VGND VPWR VPWR sky130_fd_sc_hd__fill_1
XFILLER_13_331 VGND VGND VPWR VPWR sky130_fd_sc_hd__decap_3
XFILLER_60_459 VGND VGND VPWR VPWR sky130_fd_sc_hd__decap_3
XFILLER_41_662 VGND VGND VPWR VPWR sky130_fd_sc_hd__decap_3
XFILLER_41_673 VGND VGND VPWR VPWR sky130_fd_sc_hd__decap_3
XFILLER_9_313 VGND VGND VPWR VPWR sky130_fd_sc_hd__fill_2
XFILLER_70_9 VGND VGND VPWR VPWR sky130_fd_sc_hd__fill_2
XTAP_TAPCELL_ROW_97_1420 VGND VPWR sky130_fd_sc_hd__tapvpwrvgnd_1
XFILLER_5_541 VGND VGND VPWR VPWR sky130_fd_sc_hd__decap_3
XFILLER_107_491 VGND VGND VPWR VPWR sky130_fd_sc_hd__decap_3
XFILLER_114_439 VGND VGND VPWR VPWR sky130_fd_sc_hd__decap_3
XFILLER_49_6 VGND VGND VPWR VPWR sky130_fd_sc_hd__decap_3
XFILLER_5_585 VGND VGND VPWR VPWR sky130_fd_sc_hd__decap_3
XFILLER_110_601 VGND VGND VPWR VPWR sky130_fd_sc_hd__decap_3
XFILLER_110_634 VGND VGND VPWR VPWR sky130_fd_sc_hd__decap_3
XFILLER_95_312 VGND VGND VPWR VPWR sky130_fd_sc_hd__decap_3
XFILLER_0_290 VGND VGND VPWR VPWR sky130_fd_sc_hd__decap_3
XFILLER_110_645 VGND VGND VPWR VPWR sky130_fd_sc_hd__decap_3
X_4080_ _4075_/X _4079_/X _4425_/A VGND VGND VPWR VPWR _4451_/B sky130_fd_sc_hd__o21ai_2
XFILLER_110_678 VGND VGND VPWR VPWR sky130_fd_sc_hd__decap_3
XFILLER_83_529 VGND VGND VPWR VPWR sky130_fd_sc_hd__decap_3
XFILLER_95_378 VGND VGND VPWR VPWR sky130_fd_sc_hd__fill_2
XFILLER_76_581 VGND VGND VPWR VPWR sky130_fd_sc_hd__decap_3
XFILLER_76_592 VGND VGND VPWR VPWR sky130_fd_sc_hd__decap_3
XFILLER_24_607 VGND VGND VPWR VPWR sky130_fd_sc_hd__decap_3
XFILLER_63_231 VGND VGND VPWR VPWR sky130_fd_sc_hd__decap_3
XFILLER_63_264 VGND VGND VPWR VPWR sky130_fd_sc_hd__decap_3
XFILLER_91_540 VGND VGND VPWR VPWR sky130_fd_sc_hd__decap_3
XFILLER_91_573 VGND VGND VPWR VPWR sky130_fd_sc_hd__decap_3
XFILLER_51_415 VGND VGND VPWR VPWR sky130_fd_sc_hd__decap_3
X_4982_ _6992_/Q _4982_/B _5009_/A VGND VGND VPWR VPWR _4983_/C sky130_fd_sc_hd__or3_2
XFILLER_32_640 VGND VGND VPWR VPWR sky130_fd_sc_hd__decap_3
XFILLER_32_651 VGND VGND VPWR VPWR sky130_fd_sc_hd__decap_3
Xplace297 _3926_/B1 VGND VGND VPWR VPWR _3918_/B1 sky130_fd_sc_hd__buf_2
Xplace286 _3661_/X VGND VGND VPWR VPWR _3892_/A2 sky130_fd_sc_hd__buf_2
Xplace275 _3892_/B1 VGND VGND VPWR VPWR _3888_/B1 sky130_fd_sc_hd__buf_2
X_6721_ clkload6/A _6721_/D VGND VGND VPWR VPWR _6721_/Q sky130_fd_sc_hd__dfxtp_2
X_3933_ _7373_/Q _4476_/A0 _3947_/S VGND VGND VPWR VPWR _7373_/D sky130_fd_sc_hd__mux2_2
XTAP_TAPCELL_ROW_34_657 VGND VPWR sky130_fd_sc_hd__tapvpwrvgnd_1
XFILLER_32_684 VGND VGND VPWR VPWR sky130_fd_sc_hd__decap_3
X_6652_ _6652_/A VGND VGND VPWR VPWR _6652_/Y sky130_fd_sc_hd__inv_2
X_3864_ _3864_/A0 _3863_/X _3904_/A VGND VGND VPWR VPWR _7385_/D sky130_fd_sc_hd__mux2_2
XTAP_TAPCELL_ROW_62_999 VGND VPWR sky130_fd_sc_hd__tapvpwrvgnd_1
XTAP_TAPCELL_ROW_102_1479 VGND VPWR sky130_fd_sc_hd__tapvpwrvgnd_1
X_6583_ _6622_/A VGND VGND VPWR VPWR _6583_/Y sky130_fd_sc_hd__inv_2
X_3795_ _6971_/Q _3878_/A2 _3892_/B1 _6721_/Q VGND VGND VPWR VPWR _3795_/X sky130_fd_sc_hd__a22o_2
XFILLER_8_390 VGND VGND VPWR VPWR sky130_fd_sc_hd__decap_3
XFILLER_105_406 VGND VGND VPWR VPWR sky130_fd_sc_hd__decap_3
X_7204_ _7395_/CLK _7204_/D _6484_/Y VGND VGND VPWR VPWR _7204_/Q sky130_fd_sc_hd__dfrtp_2
X_4416_ _7368_/Q _4093_/B _4436_/B1 _7176_/Q _4415_/X VGND VGND VPWR VPWR _4416_/X
+ sky130_fd_sc_hd__a221o_2
X_7135_ _7364_/CLK _7135_/D _6415_/Y VGND VGND VPWR VPWR _7135_/Q sky130_fd_sc_hd__dfrtp_2
X_5396_ _5396_/A0 _4978_/X _5409_/S VGND VGND VPWR VPWR _7135_/D sky130_fd_sc_hd__mux2_2
XFILLER_99_673 VGND VGND VPWR VPWR sky130_fd_sc_hd__decap_3
XFILLER_99_662 VGND VGND VPWR VPWR sky130_fd_sc_hd__decap_3
XFILLER_101_612 VGND VGND VPWR VPWR sky130_fd_sc_hd__decap_3
XFILLER_101_623 VGND VGND VPWR VPWR sky130_fd_sc_hd__decap_3
XFILLER_113_461 VGND VGND VPWR VPWR sky130_fd_sc_hd__decap_3
XFILLER_59_537 VGND VGND VPWR VPWR sky130_fd_sc_hd__fill_2
XFILLER_86_312 VGND VGND VPWR VPWR sky130_fd_sc_hd__decap_3
X_4347_ _7289_/Q _4517_/S _4346_/X _4347_/C1 VGND VGND VPWR VPWR _4347_/X sky130_fd_sc_hd__a211o_2
XTAP_TAPCELL_ROW_6_327 VGND VPWR sky130_fd_sc_hd__tapvpwrvgnd_1
XFILLER_100_111 VGND VGND VPWR VPWR sky130_fd_sc_hd__decap_3
XFILLER_101_656 VGND VGND VPWR VPWR sky130_fd_sc_hd__decap_3
XFILLER_113_494 VGND VGND VPWR VPWR sky130_fd_sc_hd__decap_3
XFILLER_86_356 VGND VGND VPWR VPWR sky130_fd_sc_hd__decap_3
X_7066_ _7344_/CLK _7066_/D _6346_/Y VGND VGND VPWR VPWR _7066_/Q sky130_fd_sc_hd__dfrtp_2
X_4278_ _7286_/Q _4528_/B _4278_/B1 _7350_/Q _3556_/A VGND VGND VPWR VPWR _4278_/X
+ sky130_fd_sc_hd__a221o_2
XFILLER_98_194 VGND VGND VPWR VPWR sky130_fd_sc_hd__fill_2
XFILLER_100_166 VGND VGND VPWR VPWR sky130_fd_sc_hd__decap_3
XFILLER_67_570 VGND VGND VPWR VPWR sky130_fd_sc_hd__decap_3
XFILLER_39_294 VGND VGND VPWR VPWR sky130_fd_sc_hd__decap_3
XFILLER_27_467 VGND VGND VPWR VPWR sky130_fd_sc_hd__fill_1
XFILLER_82_551 VGND VGND VPWR VPWR sky130_fd_sc_hd__decap_3
XTAP_TAPCELL_ROW_68_1065 VGND VPWR sky130_fd_sc_hd__tapvpwrvgnd_1
XFILLER_15_629 VGND VGND VPWR VPWR sky130_fd_sc_hd__decap_3
XFILLER_54_275 VGND VGND VPWR VPWR sky130_fd_sc_hd__decap_3
XFILLER_54_297 VGND VGND VPWR VPWR sky130_fd_sc_hd__decap_3
XFILLER_82_584 VGND VGND VPWR VPWR sky130_fd_sc_hd__decap_3
XFILLER_82_595 VGND VGND VPWR VPWR sky130_fd_sc_hd__decap_3
XFILLER_42_448 VGND VGND VPWR VPWR sky130_fd_sc_hd__fill_1
X_6919_ _6959_/CLK _6919_/D VGND VGND VPWR VPWR _6919_/Q sky130_fd_sc_hd__dfxtp_2
XTAP_TAPCELL_ROW_81_1221 VGND VPWR sky130_fd_sc_hd__tapvpwrvgnd_1
XFILLER_23_662 VGND VGND VPWR VPWR sky130_fd_sc_hd__decap_3
XFILLER_23_673 VGND VGND VPWR VPWR sky130_fd_sc_hd__decap_3
XFILLER_50_470 VGND VGND VPWR VPWR sky130_fd_sc_hd__decap_3
XFILLER_10_312 VGND VGND VPWR VPWR sky130_fd_sc_hd__decap_3
XFILLER_10_334 VGND VGND VPWR VPWR sky130_fd_sc_hd__decap_3
XFILLER_22_183 VGND VGND VPWR VPWR sky130_fd_sc_hd__decap_3
XFILLER_6_349 VGND VGND VPWR VPWR sky130_fd_sc_hd__decap_3
XTAP_TAPCELL_ROW_79_1194 VGND VPWR sky130_fd_sc_hd__tapvpwrvgnd_1
XFILLER_108_288 VGND VGND VPWR VPWR sky130_fd_sc_hd__fill_2
XFILLER_2_522 VGND VGND VPWR VPWR sky130_fd_sc_hd__decap_3
XFILLER_2_533 VGND VGND VPWR VPWR sky130_fd_sc_hd__decap_3
XFILLER_2_566 VGND VGND VPWR VPWR sky130_fd_sc_hd__decap_3
XTAP_TAPCELL_ROW_92_1361 VGND VPWR sky130_fd_sc_hd__tapvpwrvgnd_1
XTAP_TAPCELL_ROW_92_1350 VGND VPWR sky130_fd_sc_hd__tapvpwrvgnd_1
XFILLER_104_472 VGND VGND VPWR VPWR sky130_fd_sc_hd__decap_3
XFILLER_104_483 VGND VGND VPWR VPWR sky130_fd_sc_hd__decap_3
XFILLER_77_356 VGND VGND VPWR VPWR sky130_fd_sc_hd__decap_3
XFILLER_77_65 VGND VGND VPWR VPWR sky130_fd_sc_hd__decap_3
XFILLER_58_592 VGND VGND VPWR VPWR sky130_fd_sc_hd__decap_3
XFILLER_45_231 VGND VGND VPWR VPWR sky130_fd_sc_hd__fill_2
XFILLER_93_53 VGND VGND VPWR VPWR sky130_fd_sc_hd__decap_3
Xhold1090 _7240_/Q VGND VGND VPWR VPWR _5175_/A sky130_fd_sc_hd__dlygate4sd3_1
XFILLER_73_573 VGND VGND VPWR VPWR sky130_fd_sc_hd__decap_3
XFILLER_14_640 VGND VGND VPWR VPWR sky130_fd_sc_hd__decap_3
XFILLER_26_80 VGND VGND VPWR VPWR sky130_fd_sc_hd__decap_3
XFILLER_14_651 VGND VGND VPWR VPWR sky130_fd_sc_hd__decap_3
XFILLER_14_684 VGND VGND VPWR VPWR sky130_fd_sc_hd__decap_3
XFILLER_13_172 VGND VGND VPWR VPWR sky130_fd_sc_hd__decap_3
XFILLER_41_470 VGND VGND VPWR VPWR sky130_fd_sc_hd__decap_3
XTAP_TAPCELL_ROW_31_627 VGND VPWR sky130_fd_sc_hd__tapvpwrvgnd_1
X_3580_ _7033_/Q _4300_/B _4278_/B1 _7380_/Q VGND VGND VPWR VPWR _3580_/X sky130_fd_sc_hd__a22o_2
XFILLER_9_198 VGND VGND VPWR VPWR sky130_fd_sc_hd__decap_3
XTAP_TAPCELL_ROW_11_384 VGND VPWR sky130_fd_sc_hd__tapvpwrvgnd_1
XFILLER_47_3 VGND VGND VPWR VPWR sky130_fd_sc_hd__decap_3
X_4201_ _4186_/A _4636_/B _4200_/X VGND VGND VPWR VPWR _4201_/X sky130_fd_sc_hd__o21a_2
XFILLER_96_610 VGND VGND VPWR VPWR sky130_fd_sc_hd__decap_3
XFILLER_110_442 VGND VGND VPWR VPWR sky130_fd_sc_hd__decap_3
XFILLER_96_643 VGND VGND VPWR VPWR sky130_fd_sc_hd__fill_1
XFILLER_96_654 VGND VGND VPWR VPWR sky130_fd_sc_hd__decap_3
X_4132_ _7075_/Q _4265_/B _4432_/B1 _4131_/X VGND VGND VPWR VPWR _4207_/A sky130_fd_sc_hd__o211ai_2
XFILLER_110_475 VGND VGND VPWR VPWR sky130_fd_sc_hd__fill_1
XFILLER_49_570 VGND VGND VPWR VPWR sky130_fd_sc_hd__decap_3
XFILLER_56_529 VGND VGND VPWR VPWR sky130_fd_sc_hd__decap_3
XFILLER_96_687 VGND VGND VPWR VPWR sky130_fd_sc_hd__decap_3
X_4063_ _7116_/Q _4434_/A2 _4434_/B1 _7148_/Q VGND VGND VPWR VPWR _4063_/X sky130_fd_sc_hd__a22o_2
XTAP_TAPCELL_ROW_39_716 VGND VPWR sky130_fd_sc_hd__tapvpwrvgnd_1
XFILLER_110_486 VGND VGND VPWR VPWR sky130_fd_sc_hd__decap_3
XFILLER_83_337 VGND VGND VPWR VPWR sky130_fd_sc_hd__decap_3
XFILLER_36_242 VGND VGND VPWR VPWR sky130_fd_sc_hd__decap_3
XFILLER_36_253 VGND VGND VPWR VPWR sky130_fd_sc_hd__decap_3
XFILLER_64_551 VGND VGND VPWR VPWR sky130_fd_sc_hd__decap_3
XFILLER_64_584 VGND VGND VPWR VPWR sky130_fd_sc_hd__decap_3
XFILLER_64_595 VGND VGND VPWR VPWR sky130_fd_sc_hd__decap_3
XFILLER_51_223 VGND VGND VPWR VPWR sky130_fd_sc_hd__fill_1
XFILLER_51_245 VGND VGND VPWR VPWR sky130_fd_sc_hd__decap_3
X_4965_ _4965_/A0 _4964_/X _4979_/S VGND VGND VPWR VPWR _7264_/D sky130_fd_sc_hd__mux2_2
XTAP_TAPCELL_ROW_19_484 VGND VPWR sky130_fd_sc_hd__tapvpwrvgnd_1
XFILLER_51_278 VGND VGND VPWR VPWR sky130_fd_sc_hd__fill_2
XFILLER_51_289 VGND VGND VPWR VPWR sky130_fd_sc_hd__decap_3
X_6704_ _7378_/CLK _6704_/D VGND VGND VPWR VPWR _6704_/Q sky130_fd_sc_hd__dfxtp_2
XFILLER_20_610 VGND VGND VPWR VPWR sky130_fd_sc_hd__decap_3
XFILLER_20_643 VGND VGND VPWR VPWR sky130_fd_sc_hd__fill_1
X_4896_ _4896_/A _4896_/B VGND VGND VPWR VPWR _4896_/Y sky130_fd_sc_hd__nand2_2
XFILLER_20_654 VGND VGND VPWR VPWR sky130_fd_sc_hd__decap_3
X_6635_ _6635_/A VGND VGND VPWR VPWR _6635_/Y sky130_fd_sc_hd__inv_2
X_3847_ _6946_/Q _3893_/B1 _3887_/B1 _6958_/Q _3846_/X VGND VGND VPWR VPWR _3847_/X
+ sky130_fd_sc_hd__a221o_2
XFILLER_20_687 VGND VGND VPWR VPWR sky130_fd_sc_hd__decap_3
X_6566_ _6566_/A VGND VGND VPWR VPWR _6566_/Y sky130_fd_sc_hd__inv_2
X_3778_ _6930_/Q _3661_/X _3887_/B1 _6882_/Q VGND VGND VPWR VPWR _3778_/X sky130_fd_sc_hd__a22o_2
XTAP_TAPCELL_ROW_115_1626 VGND VPWR sky130_fd_sc_hd__tapvpwrvgnd_1
X_6497_ _6603_/A VGND VGND VPWR VPWR _6497_/Y sky130_fd_sc_hd__inv_2
XTAP_TAPCELL_ROW_115_1637 VGND VPWR sky130_fd_sc_hd__tapvpwrvgnd_1
XFILLER_105_269 VGND VGND VPWR VPWR sky130_fd_sc_hd__decap_3
Xoutput462 _5658_/B VGND VGND VPWR VPWR alu_result_out[12] sky130_fd_sc_hd__clkdlybuf4s25_1
Xoutput495 _3525_/B VGND VGND VPWR VPWR instruction_out[14] sky130_fd_sc_hd__clkdlybuf4s25_1
Xoutput484 _3640_/X VGND VGND VPWR VPWR alu_result_out[3] sky130_fd_sc_hd__clkdlybuf4s25_1
Xoutput473 _5663_/C VGND VGND VPWR VPWR alu_result_out[22] sky130_fd_sc_hd__clkdlybuf4s25_1
X_5379_ _5379_/A0 _4836_/X _5383_/S VGND VGND VPWR VPWR _7143_/D sky130_fd_sc_hd__mux2_2
XFILLER_87_632 VGND VGND VPWR VPWR sky130_fd_sc_hd__decap_3
X_7118_ _7406_/CLK _7118_/D _6398_/Y VGND VGND VPWR VPWR _7118_/Q sky130_fd_sc_hd__dfrtp_2
XFILLER_99_492 VGND VGND VPWR VPWR sky130_fd_sc_hd__decap_3
XFILLER_74_315 VGND VGND VPWR VPWR sky130_fd_sc_hd__decap_3
XFILLER_87_665 VGND VGND VPWR VPWR sky130_fd_sc_hd__decap_3
XFILLER_87_676 VGND VGND VPWR VPWR sky130_fd_sc_hd__decap_3
X_7049_ _7404_/CLK _7049_/D _6329_/Y VGND VGND VPWR VPWR _7049_/Q sky130_fd_sc_hd__dfrtp_2
XFILLER_101_486 VGND VGND VPWR VPWR sky130_fd_sc_hd__decap_3
XFILLER_74_348 VGND VGND VPWR VPWR sky130_fd_sc_hd__decap_3
XFILLER_86_197 VGND VGND VPWR VPWR sky130_fd_sc_hd__decap_3
XPHY_EDGE_ROW_29_Right_29 VGND VGND VPWR VPWR sky130_fd_sc_hd__decap_3
XFILLER_55_573 VGND VGND VPWR VPWR sky130_fd_sc_hd__decap_3
XFILLER_63_12 VGND VGND VPWR VPWR sky130_fd_sc_hd__decap_3
XFILLER_70_521 VGND VGND VPWR VPWR sky130_fd_sc_hd__fill_2
XFILLER_70_543 VGND VGND VPWR VPWR sky130_fd_sc_hd__decap_3
XFILLER_63_78 VGND VGND VPWR VPWR sky130_fd_sc_hd__decap_3
XFILLER_70_576 VGND VGND VPWR VPWR sky130_fd_sc_hd__decap_3
XFILLER_11_632 VGND VGND VPWR VPWR sky130_fd_sc_hd__decap_3
XFILLER_70_598 VGND VGND VPWR VPWR sky130_fd_sc_hd__decap_3
XFILLER_10_131 VGND VGND VPWR VPWR sky130_fd_sc_hd__fill_1
XFILLER_11_665 VGND VGND VPWR VPWR sky130_fd_sc_hd__decap_3
XFILLER_11_676 VGND VGND VPWR VPWR sky130_fd_sc_hd__decap_3
XFILLER_7_603 VGND VGND VPWR VPWR sky130_fd_sc_hd__decap_3
XPHY_EDGE_ROW_38_Right_38 VGND VGND VPWR VPWR sky130_fd_sc_hd__decap_3
XFILLER_109_520 VGND VGND VPWR VPWR sky130_fd_sc_hd__decap_3
XFILLER_7_647 VGND VGND VPWR VPWR sky130_fd_sc_hd__decap_3
XFILLER_109_553 VGND VGND VPWR VPWR sky130_fd_sc_hd__decap_3
XFILLER_109_564 VGND VGND VPWR VPWR sky130_fd_sc_hd__decap_3
XFILLER_109_597 VGND VGND VPWR VPWR sky130_fd_sc_hd__decap_3
XFILLER_12_93 VGND VGND VPWR VPWR sky130_fd_sc_hd__fill_2
XFILLER_69_109 VGND VGND VPWR VPWR sky130_fd_sc_hd__decap_3
XFILLER_78_610 VGND VGND VPWR VPWR sky130_fd_sc_hd__decap_3
XFILLER_88_97 VGND VGND VPWR VPWR sky130_fd_sc_hd__decap_3
XFILLER_78_643 VGND VGND VPWR VPWR sky130_fd_sc_hd__fill_1
XFILLER_78_654 VGND VGND VPWR VPWR sky130_fd_sc_hd__decap_3
XFILLER_38_518 VGND VGND VPWR VPWR sky130_fd_sc_hd__decap_3
XFILLER_77_153 VGND VGND VPWR VPWR sky130_fd_sc_hd__decap_3
XFILLER_78_687 VGND VGND VPWR VPWR sky130_fd_sc_hd__decap_3
XPHY_EDGE_ROW_47_Right_47 VGND VGND VPWR VPWR sky130_fd_sc_hd__decap_3
XFILLER_93_635 VGND VGND VPWR VPWR sky130_fd_sc_hd__decap_3
XFILLER_93_668 VGND VGND VPWR VPWR sky130_fd_sc_hd__decap_3
XFILLER_93_679 VGND VGND VPWR VPWR sky130_fd_sc_hd__decap_3
XFILLER_33_212 VGND VGND VPWR VPWR sky130_fd_sc_hd__decap_3
XFILLER_46_573 VGND VGND VPWR VPWR sky130_fd_sc_hd__decap_3
XFILLER_46_595 VGND VGND VPWR VPWR sky130_fd_sc_hd__decap_3
XFILLER_33_234 VGND VGND VPWR VPWR sky130_fd_sc_hd__decap_3
XFILLER_61_554 VGND VGND VPWR VPWR sky130_fd_sc_hd__decap_3
XFILLER_33_267 VGND VGND VPWR VPWR sky130_fd_sc_hd__decap_3
XFILLER_61_576 VGND VGND VPWR VPWR sky130_fd_sc_hd__decap_3
XTAP_TAPCELL_ROW_44_774 VGND VPWR sky130_fd_sc_hd__tapvpwrvgnd_1
XTAP_TAPCELL_ROW_16_443 VGND VPWR sky130_fd_sc_hd__tapvpwrvgnd_1
X_4750_ _4960_/A _4750_/B _4750_/C VGND VGND VPWR VPWR _4751_/B sky130_fd_sc_hd__or3_2
XTAP_TAPCELL_ROW_44_785 VGND VPWR sky130_fd_sc_hd__tapvpwrvgnd_1
XPHY_EDGE_ROW_56_Right_56 VGND VGND VPWR VPWR sky130_fd_sc_hd__decap_3
X_4681_ _4982_/B _5009_/A _6992_/Q _6993_/Q _6994_/Q VGND VGND VPWR VPWR _4960_/B
+ sky130_fd_sc_hd__o2111a_2
X_3701_ _3682_/A _3700_/X _4791_/A1 VGND VGND VPWR VPWR _3701_/X sky130_fd_sc_hd__a21o_2
X_6420_ _6610_/A VGND VGND VPWR VPWR _6420_/Y sky130_fd_sc_hd__inv_2
X_3632_ _3630_/A _3501_/X _3502_/X _3505_/B _5020_/A VGND VGND VPWR VPWR _3632_/X
+ sky130_fd_sc_hd__a311o_2
X_6351_ _6673_/A VGND VGND VPWR VPWR _6351_/Y sky130_fd_sc_hd__inv_2
XFILLER_115_523 VGND VGND VPWR VPWR sky130_fd_sc_hd__decap_3
X_5302_ _5302_/A0 _4771_/X _5315_/S VGND VGND VPWR VPWR _7179_/D sky130_fd_sc_hd__mux2_2
XFILLER_115_556 VGND VGND VPWR VPWR sky130_fd_sc_hd__decap_3
XFILLER_115_567 VGND VGND VPWR VPWR sky130_fd_sc_hd__decap_3
XFILLER_5_190 VGND VGND VPWR VPWR sky130_fd_sc_hd__decap_3
XFILLER_88_407 VGND VGND VPWR VPWR sky130_fd_sc_hd__decap_3
X_6282_ _6462_/A VGND VGND VPWR VPWR _6282_/Y sky130_fd_sc_hd__inv_2
X_3494_ _7183_/Q _4471_/S _3380_/Y _7375_/Q VGND VGND VPWR VPWR _3494_/X sky130_fd_sc_hd__a22o_2
XPHY_EDGE_ROW_65_Right_65 VGND VGND VPWR VPWR sky130_fd_sc_hd__decap_3
XFILLER_68_131 VGND VGND VPWR VPWR sky130_fd_sc_hd__decap_3
XFILLER_69_632 VGND VGND VPWR VPWR sky130_fd_sc_hd__decap_3
XFILLER_68_153 VGND VGND VPWR VPWR sky130_fd_sc_hd__decap_3
XFILLER_69_665 VGND VGND VPWR VPWR sky130_fd_sc_hd__decap_3
XFILLER_69_676 VGND VGND VPWR VPWR sky130_fd_sc_hd__decap_3
XFILLER_84_613 VGND VGND VPWR VPWR sky130_fd_sc_hd__decap_3
X_4115_ _7268_/Q _4422_/A2 _4421_/A2 _7236_/Q _4114_/X VGND VGND VPWR VPWR _4117_/B
+ sky130_fd_sc_hd__a221o_2
XTAP_TAPCELL_ROW_110_1567 VGND VPWR sky130_fd_sc_hd__tapvpwrvgnd_1
XFILLER_56_315 VGND VGND VPWR VPWR sky130_fd_sc_hd__decap_3
XFILLER_68_186 VGND VGND VPWR VPWR sky130_fd_sc_hd__decap_3
XFILLER_68_197 VGND VGND VPWR VPWR sky130_fd_sc_hd__decap_3
X_5095_ _5095_/A0 _5094_/X _5108_/S VGND VGND VPWR VPWR _7256_/D sky130_fd_sc_hd__mux2_2
XFILLER_56_359 VGND VGND VPWR VPWR sky130_fd_sc_hd__decap_3
XFILLER_71_307 VGND VGND VPWR VPWR sky130_fd_sc_hd__decap_3
XFILLER_84_657 VGND VGND VPWR VPWR sky130_fd_sc_hd__decap_3
X_4046_ _7373_/Q _4394_/B _4436_/B1 _7181_/Q VGND VGND VPWR VPWR _4046_/X sky130_fd_sc_hd__a22o_2
XFILLER_37_573 VGND VGND VPWR VPWR sky130_fd_sc_hd__decap_3
XFILLER_92_690 VGND VGND VPWR VPWR sky130_fd_sc_hd__fill_1
XTAP_TAPCELL_ROW_65_1035 VGND VPWR sky130_fd_sc_hd__tapvpwrvgnd_1
XFILLER_24_256 VGND VGND VPWR VPWR sky130_fd_sc_hd__decap_3
XPHY_EDGE_ROW_74_Right_74 VGND VGND VPWR VPWR sky130_fd_sc_hd__decap_3
XFILLER_24_289 VGND VGND VPWR VPWR sky130_fd_sc_hd__decap_3
XFILLER_52_598 VGND VGND VPWR VPWR sky130_fd_sc_hd__decap_3
X_4948_ _4948_/A _4948_/B VGND VGND VPWR VPWR _4948_/Y sky130_fd_sc_hd__nor2_2
XFILLER_20_440 VGND VGND VPWR VPWR sky130_fd_sc_hd__decap_3
X_4879_ _4879_/A0 _4878_/X _4946_/S VGND VGND VPWR VPWR _7269_/D sky130_fd_sc_hd__mux2_2
X_6618_ _6618_/A VGND VGND VPWR VPWR _6618_/Y sky130_fd_sc_hd__inv_2
XFILLER_116_6 VGND VGND VPWR VPWR sky130_fd_sc_hd__fill_1
XFILLER_106_501 VGND VGND VPWR VPWR sky130_fd_sc_hd__decap_3
XFILLER_4_628 VGND VGND VPWR VPWR sky130_fd_sc_hd__decap_3
X_6549_ _6654_/A VGND VGND VPWR VPWR _6549_/Y sky130_fd_sc_hd__inv_2
XFILLER_106_545 VGND VGND VPWR VPWR sky130_fd_sc_hd__decap_3
XTAP_TAPCELL_ROW_76_1164 VGND VPWR sky130_fd_sc_hd__tapvpwrvgnd_1
XPHY_EDGE_ROW_83_Right_83 VGND VGND VPWR VPWR sky130_fd_sc_hd__decap_3
XPHY_EDGE_ROW_18_Left_135 VGND VGND VPWR VPWR sky130_fd_sc_hd__decap_3
XFILLER_106_578 VGND VGND VPWR VPWR sky130_fd_sc_hd__decap_3
XFILLER_106_589 VGND VGND VPWR VPWR sky130_fd_sc_hd__decap_3
XFILLER_58_56 VGND VGND VPWR VPWR sky130_fd_sc_hd__decap_3
XFILLER_47_326 VGND VGND VPWR VPWR sky130_fd_sc_hd__decap_3
XFILLER_47_337 VGND VGND VPWR VPWR sky130_fd_sc_hd__decap_3
XFILLER_74_112 VGND VGND VPWR VPWR sky130_fd_sc_hd__decap_3
XFILLER_75_635 VGND VGND VPWR VPWR sky130_fd_sc_hd__decap_3
XFILLER_114_62 VGND VGND VPWR VPWR sky130_fd_sc_hd__decap_3
XFILLER_28_551 VGND VGND VPWR VPWR sky130_fd_sc_hd__decap_3
XFILLER_75_668 VGND VGND VPWR VPWR sky130_fd_sc_hd__decap_3
XFILLER_75_679 VGND VGND VPWR VPWR sky130_fd_sc_hd__decap_3
XFILLER_28_584 VGND VGND VPWR VPWR sky130_fd_sc_hd__decap_3
XFILLER_74_189 VGND VGND VPWR VPWR sky130_fd_sc_hd__decap_3
XFILLER_90_616 VGND VGND VPWR VPWR sky130_fd_sc_hd__decap_3
XPHY_EDGE_ROW_27_Left_144 VGND VGND VPWR VPWR sky130_fd_sc_hd__decap_3
XFILLER_15_212 VGND VGND VPWR VPWR sky130_fd_sc_hd__fill_1
XFILLER_15_234 VGND VGND VPWR VPWR sky130_fd_sc_hd__decap_3
XFILLER_28_595 VGND VGND VPWR VPWR sky130_fd_sc_hd__decap_3
XFILLER_74_88 VGND VGND VPWR VPWR sky130_fd_sc_hd__decap_3
XTAP_TAPCELL_ROW_87_1293 VGND VPWR sky130_fd_sc_hd__tapvpwrvgnd_1
XPHY_EDGE_ROW_92_Right_92 VGND VGND VPWR VPWR sky130_fd_sc_hd__decap_3
XFILLER_43_554 VGND VGND VPWR VPWR sky130_fd_sc_hd__decap_3
XFILLER_43_576 VGND VGND VPWR VPWR sky130_fd_sc_hd__decap_3
XFILLER_30_215 VGND VGND VPWR VPWR sky130_fd_sc_hd__decap_3
XTAP_TAPCELL_ROW_13_413 VGND VPWR sky130_fd_sc_hd__tapvpwrvgnd_1
XTAP_TAPCELL_ROW_13_402 VGND VPWR sky130_fd_sc_hd__tapvpwrvgnd_1
XFILLER_11_440 VGND VGND VPWR VPWR sky130_fd_sc_hd__decap_3
XFILLER_30_259 VGND VGND VPWR VPWR sky130_fd_sc_hd__decap_3
XTAP_TAPCELL_ROW_41_744 VGND VPWR sky130_fd_sc_hd__tapvpwrvgnd_1
XFILLER_7_400 VGND VGND VPWR VPWR sky130_fd_sc_hd__decap_3
XFILLER_116_309 VGND VGND VPWR VPWR sky130_fd_sc_hd__decap_3
XFILLER_7_444 VGND VGND VPWR VPWR sky130_fd_sc_hd__decap_3
XPHY_EDGE_ROW_36_Left_153 VGND VGND VPWR VPWR sky130_fd_sc_hd__decap_3
XFILLER_109_383 VGND VGND VPWR VPWR sky130_fd_sc_hd__fill_1
XFILLER_112_504 VGND VGND VPWR VPWR sky130_fd_sc_hd__decap_3
XFILLER_3_650 VGND VGND VPWR VPWR sky130_fd_sc_hd__decap_3
XFILLER_112_548 VGND VGND VPWR VPWR sky130_fd_sc_hd__decap_3
XFILLER_97_248 VGND VGND VPWR VPWR sky130_fd_sc_hd__fill_1
XFILLER_2_193 VGND VGND VPWR VPWR sky130_fd_sc_hd__decap_3
XFILLER_66_613 VGND VGND VPWR VPWR sky130_fd_sc_hd__decap_3
XFILLER_78_440 VGND VGND VPWR VPWR sky130_fd_sc_hd__decap_3
XFILLER_38_315 VGND VGND VPWR VPWR sky130_fd_sc_hd__decap_3
XFILLER_19_540 VGND VGND VPWR VPWR sky130_fd_sc_hd__decap_3
XFILLER_38_348 VGND VGND VPWR VPWR sky130_fd_sc_hd__decap_3
XFILLER_65_145 VGND VGND VPWR VPWR sky130_fd_sc_hd__decap_3
XFILLER_66_657 VGND VGND VPWR VPWR sky130_fd_sc_hd__decap_3
XFILLER_93_465 VGND VGND VPWR VPWR sky130_fd_sc_hd__decap_3
XTAP_TAPCELL_ROW_49_844 VGND VPWR sky130_fd_sc_hd__tapvpwrvgnd_1
XPHY_EDGE_ROW_45_Left_162 VGND VGND VPWR VPWR sky130_fd_sc_hd__decap_3
XFILLER_19_573 VGND VGND VPWR VPWR sky130_fd_sc_hd__decap_3
XFILLER_81_638 VGND VGND VPWR VPWR sky130_fd_sc_hd__decap_3
XFILLER_34_543 VGND VGND VPWR VPWR sky130_fd_sc_hd__decap_3
XFILLER_74_690 VGND VGND VPWR VPWR sky130_fd_sc_hd__fill_1
XFILLER_34_565 VGND VGND VPWR VPWR sky130_fd_sc_hd__decap_3
XFILLER_80_159 VGND VGND VPWR VPWR sky130_fd_sc_hd__decap_3
XFILLER_21_237 VGND VGND VPWR VPWR sky130_fd_sc_hd__decap_3
XFILLER_34_598 VGND VGND VPWR VPWR sky130_fd_sc_hd__decap_3
X_4802_ _7002_/Q _5622_/B _4834_/A VGND VGND VPWR VPWR _4802_/X sky130_fd_sc_hd__o21a_2
XPHY_EDGE_ROW_100_Right_100 VGND VGND VPWR VPWR sky130_fd_sc_hd__decap_3
XPHY_EDGE_ROW_54_Left_171 VGND VGND VPWR VPWR sky130_fd_sc_hd__decap_3
XFILLER_107_309 VGND VGND VPWR VPWR sky130_fd_sc_hd__decap_3
X_6403_ _6596_/A VGND VGND VPWR VPWR _6403_/Y sky130_fd_sc_hd__inv_2
X_4664_ _4927_/A _4664_/B _5665_/A VGND VGND VPWR VPWR _4664_/X sky130_fd_sc_hd__or3b_4
X_7383_ _7383_/CLK _7383_/D _6663_/Y VGND VGND VPWR VPWR _7383_/Q sky130_fd_sc_hd__dfrtp_2
Xhold901 _7085_/Q VGND VGND VPWR VPWR _7085_/D sky130_fd_sc_hd__dlygate4sd3_1
Xhold912 _6690_/Q VGND VGND VPWR VPWR hold912/X sky130_fd_sc_hd__dlygate4sd3_1
X_4595_ _4595_/A _4595_/B VGND VGND VPWR VPWR _7283_/D sky130_fd_sc_hd__and2_2
X_3615_ _3508_/A _3547_/Y _3427_/B VGND VGND VPWR VPWR _3616_/B sky130_fd_sc_hd__o21ai_2
XFILLER_115_342 VGND VGND VPWR VPWR sky130_fd_sc_hd__decap_3
Xhold923 _6698_/Q VGND VGND VPWR VPWR hold923/X sky130_fd_sc_hd__dlygate4sd3_1
Xhold945 _7392_/Q VGND VGND VPWR VPWR hold945/X sky130_fd_sc_hd__dlygate4sd3_1
Xhold934 _7020_/Q VGND VGND VPWR VPWR _5615_/A sky130_fd_sc_hd__dlygate4sd3_1
X_6334_ _6652_/A VGND VGND VPWR VPWR _6334_/Y sky130_fd_sc_hd__inv_2
X_3546_ _3630_/A _3630_/B _3635_/A _3636_/A VGND VGND VPWR VPWR _3547_/B sky130_fd_sc_hd__a211o_2
XFILLER_103_526 VGND VGND VPWR VPWR sky130_fd_sc_hd__decap_3
Xhold989 _7021_/Q VGND VGND VPWR VPWR _5613_/A sky130_fd_sc_hd__dlygate4sd3_1
Xhold978 _7050_/Q VGND VGND VPWR VPWR hold978/X sky130_fd_sc_hd__dlygate4sd3_1
Xhold967 _7019_/Q VGND VGND VPWR VPWR _5617_/A sky130_fd_sc_hd__dlygate4sd3_1
Xhold956 _7052_/Q VGND VGND VPWR VPWR hold956/X sky130_fd_sc_hd__dlygate4sd3_1
X_6265_ _6673_/A VGND VGND VPWR VPWR _6265_/Y sky130_fd_sc_hd__inv_2
XFILLER_103_559 VGND VGND VPWR VPWR sky130_fd_sc_hd__fill_1
XFILLER_115_386 VGND VGND VPWR VPWR sky130_fd_sc_hd__decap_3
XFILLER_88_226 VGND VGND VPWR VPWR sky130_fd_sc_hd__decap_3
X_3477_ _7184_/Q _3996_/S _4285_/B1 _7376_/Q VGND VGND VPWR VPWR _3477_/X sky130_fd_sc_hd__a22o_2
XFILLER_88_259 VGND VGND VPWR VPWR sky130_fd_sc_hd__decap_3
XFILLER_111_570 VGND VGND VPWR VPWR sky130_fd_sc_hd__decap_3
XFILLER_29_337 VGND VGND VPWR VPWR sky130_fd_sc_hd__decap_3
XFILLER_57_635 VGND VGND VPWR VPWR sky130_fd_sc_hd__decap_3
XFILLER_84_421 VGND VGND VPWR VPWR sky130_fd_sc_hd__fill_1
X_5147_ _5145_/A _3541_/X _5146_/Y VGND VGND VPWR VPWR _5147_/X sky130_fd_sc_hd__a21o_2
XPHY_EDGE_ROW_63_Left_180 VGND VGND VPWR VPWR sky130_fd_sc_hd__decap_3
XFILLER_57_668 VGND VGND VPWR VPWR sky130_fd_sc_hd__decap_3
XFILLER_57_679 VGND VGND VPWR VPWR sky130_fd_sc_hd__decap_3
X_5078_ _5593_/B _5069_/X _5077_/X _4467_/B _5666_/A VGND VGND VPWR VPWR _5078_/X
+ sky130_fd_sc_hd__a221o_2
XFILLER_56_189 VGND VGND VPWR VPWR sky130_fd_sc_hd__decap_3
XFILLER_72_616 VGND VGND VPWR VPWR sky130_fd_sc_hd__decap_3
XFILLER_71_137 VGND VGND VPWR VPWR sky130_fd_sc_hd__decap_3
XFILLER_25_554 VGND VGND VPWR VPWR sky130_fd_sc_hd__decap_3
XFILLER_25_576 VGND VGND VPWR VPWR sky130_fd_sc_hd__decap_3
XFILLER_44_47 VGND VGND VPWR VPWR sky130_fd_sc_hd__decap_3
XFILLER_80_660 VGND VGND VPWR VPWR sky130_fd_sc_hd__decap_3
XFILLER_12_248 VGND VGND VPWR VPWR sky130_fd_sc_hd__decap_3
XFILLER_40_557 VGND VGND VPWR VPWR sky130_fd_sc_hd__decap_3
XFILLER_60_35 VGND VGND VPWR VPWR sky130_fd_sc_hd__decap_3
XFILLER_114_3 VGND VGND VPWR VPWR sky130_fd_sc_hd__decap_3
XFILLER_106_342 VGND VGND VPWR VPWR sky130_fd_sc_hd__decap_3
XFILLER_4_469 VGND VGND VPWR VPWR sky130_fd_sc_hd__decap_3
XFILLER_79_215 VGND VGND VPWR VPWR sky130_fd_sc_hd__decap_3
XFILLER_0_620 VGND VGND VPWR VPWR sky130_fd_sc_hd__decap_3
XFILLER_0_631 VGND VGND VPWR VPWR sky130_fd_sc_hd__decap_3
XFILLER_102_581 VGND VGND VPWR VPWR sky130_fd_sc_hd__decap_3
XFILLER_48_613 VGND VGND VPWR VPWR sky130_fd_sc_hd__decap_3
XFILLER_75_410 VGND VGND VPWR VPWR sky130_fd_sc_hd__decap_3
XFILLER_85_21 VGND VGND VPWR VPWR sky130_fd_sc_hd__fill_2
XFILLER_85_43 VGND VGND VPWR VPWR sky130_fd_sc_hd__decap_3
XTAP_TAPCELL_ROW_89_1322 VGND VPWR sky130_fd_sc_hd__tapvpwrvgnd_1
XFILLER_102_592 VGND VGND VPWR VPWR sky130_fd_sc_hd__decap_3
XFILLER_48_657 VGND VGND VPWR VPWR sky130_fd_sc_hd__decap_3
XFILLER_85_65 VGND VGND VPWR VPWR sky130_fd_sc_hd__decap_3
XFILLER_63_638 VGND VGND VPWR VPWR sky130_fd_sc_hd__decap_3
XTAP_TAPCELL_ROW_46_803 VGND VPWR sky130_fd_sc_hd__tapvpwrvgnd_1
XFILLER_18_81 VGND VGND VPWR VPWR sky130_fd_sc_hd__decap_3
XFILLER_56_690 VGND VGND VPWR VPWR sky130_fd_sc_hd__fill_1
XFILLER_16_554 VGND VGND VPWR VPWR sky130_fd_sc_hd__decap_3
XFILLER_43_362 VGND VGND VPWR VPWR sky130_fd_sc_hd__decap_3
XFILLER_71_671 VGND VGND VPWR VPWR sky130_fd_sc_hd__fill_1
XFILLER_16_587 VGND VGND VPWR VPWR sky130_fd_sc_hd__fill_1
XFILLER_16_598 VGND VGND VPWR VPWR sky130_fd_sc_hd__decap_3
XFILLER_31_524 VGND VGND VPWR VPWR sky130_fd_sc_hd__fill_2
XFILLER_71_682 VGND VGND VPWR VPWR sky130_fd_sc_hd__decap_3
XTAP_TAPCELL_ROW_26_560 VGND VPWR sky130_fd_sc_hd__tapvpwrvgnd_1
XFILLER_31_579 VGND VGND VPWR VPWR sky130_fd_sc_hd__decap_3
XFILLER_116_106 VGND VGND VPWR VPWR sky130_fd_sc_hd__decap_3
XFILLER_116_128 VGND VGND VPWR VPWR sky130_fd_sc_hd__decap_3
XFILLER_7_274 VGND VGND VPWR VPWR sky130_fd_sc_hd__decap_3
X_4380_ _4380_/A _4380_/B VGND VGND VPWR VPWR _4381_/B sky130_fd_sc_hd__or2_2
X_3400_ _3449_/B VGND VGND VPWR VPWR _3421_/B sky130_fd_sc_hd__inv_2
X_3331_ _3365_/A _3331_/B _6981_/Q VGND VGND VPWR VPWR _3528_/A sky130_fd_sc_hd__or3b_2
XFILLER_98_513 VGND VGND VPWR VPWR sky130_fd_sc_hd__decap_3
XFILLER_112_312 VGND VGND VPWR VPWR sky130_fd_sc_hd__decap_3
XFILLER_98_557 VGND VGND VPWR VPWR sky130_fd_sc_hd__decap_3
XFILLER_100_507 VGND VGND VPWR VPWR sky130_fd_sc_hd__decap_3
XFILLER_39_635 VGND VGND VPWR VPWR sky130_fd_sc_hd__decap_3
XFILLER_66_421 VGND VGND VPWR VPWR sky130_fd_sc_hd__decap_3
X_5001_ _5001_/A _5001_/B VGND VGND VPWR VPWR _6991_/D sky130_fd_sc_hd__nor2_2
XFILLER_39_668 VGND VGND VPWR VPWR sky130_fd_sc_hd__decap_3
XFILLER_26_318 VGND VGND VPWR VPWR sky130_fd_sc_hd__fill_2
XFILLER_39_679 VGND VGND VPWR VPWR sky130_fd_sc_hd__decap_3
XFILLER_54_616 VGND VGND VPWR VPWR sky130_fd_sc_hd__decap_3
XFILLER_93_262 VGND VGND VPWR VPWR sky130_fd_sc_hd__decap_3
XFILLER_93_273 VGND VGND VPWR VPWR sky130_fd_sc_hd__decap_3
XFILLER_53_148 VGND VGND VPWR VPWR sky130_fd_sc_hd__decap_3
X_6952_ clkload8/A _6952_/D VGND VGND VPWR VPWR _6952_/Q sky130_fd_sc_hd__dfxtp_2
XFILLER_34_351 VGND VGND VPWR VPWR sky130_fd_sc_hd__decap_3
XFILLER_62_660 VGND VGND VPWR VPWR sky130_fd_sc_hd__decap_3
X_6883_ _6965_/CLK _6883_/D VGND VGND VPWR VPWR _6883_/Q sky130_fd_sc_hd__dfxtp_2
XFILLER_34_395 VGND VGND VPWR VPWR sky130_fd_sc_hd__fill_2
XFILLER_22_568 VGND VGND VPWR VPWR sky130_fd_sc_hd__decap_3
XFILLER_61_181 VGND VGND VPWR VPWR sky130_fd_sc_hd__fill_2
XFILLER_108_607 VGND VGND VPWR VPWR sky130_fd_sc_hd__decap_3
X_4716_ _5092_/C _4664_/X _4695_/X _7008_/D _4997_/A1 VGND VGND VPWR VPWR _4716_/X
+ sky130_fd_sc_hd__a32o_2
X_4647_ _4813_/A _4827_/A _4795_/A _4787_/A VGND VGND VPWR VPWR _4647_/X sky130_fd_sc_hd__and4_2
XFILLER_116_640 VGND VGND VPWR VPWR sky130_fd_sc_hd__decap_3
X_7366_ _7406_/CLK _7366_/D _6646_/Y VGND VGND VPWR VPWR _7366_/Q sky130_fd_sc_hd__dfrtp_2
Xhold720 _6893_/Q VGND VGND VPWR VPWR _6893_/D sky130_fd_sc_hd__dlygate4sd3_1
XFILLER_100_9 VGND VGND VPWR VPWR sky130_fd_sc_hd__decap_3
XFILLER_116_662 VGND VGND VPWR VPWR sky130_fd_sc_hd__fill_2
XFILLER_116_673 VGND VGND VPWR VPWR sky130_fd_sc_hd__decap_3
Xhold731 _6809_/Q VGND VGND VPWR VPWR _6809_/D sky130_fd_sc_hd__dlygate4sd3_1
Xhold742 _6720_/Q VGND VGND VPWR VPWR _6720_/D sky130_fd_sc_hd__dlygate4sd3_1
Xhold753 _6759_/Q VGND VGND VPWR VPWR _6759_/D sky130_fd_sc_hd__dlygate4sd3_1
Xhold764 _6911_/Q VGND VGND VPWR VPWR _6911_/D sky130_fd_sc_hd__dlygate4sd3_1
X_6317_ _6633_/A VGND VGND VPWR VPWR _6317_/Y sky130_fd_sc_hd__inv_2
XTAP_TAPCELL_ROW_73_1123 VGND VPWR sky130_fd_sc_hd__tapvpwrvgnd_1
XFILLER_115_172 VGND VGND VPWR VPWR sky130_fd_sc_hd__decap_3
XFILLER_89_535 VGND VGND VPWR VPWR sky130_fd_sc_hd__decap_3
X_7297_ _7332_/CLK _7297_/D _6577_/Y VGND VGND VPWR VPWR _7297_/Q sky130_fd_sc_hd__dfrtp_2
Xhold775 _6803_/Q VGND VGND VPWR VPWR _6803_/D sky130_fd_sc_hd__dlygate4sd3_1
Xhold786 _6797_/Q VGND VGND VPWR VPWR _6797_/D sky130_fd_sc_hd__dlygate4sd3_1
Xhold797 _6887_/Q VGND VGND VPWR VPWR _6887_/D sky130_fd_sc_hd__dlygate4sd3_1
XFILLER_89_579 VGND VGND VPWR VPWR sky130_fd_sc_hd__decap_3
XFILLER_103_378 VGND VGND VPWR VPWR sky130_fd_sc_hd__decap_3
XFILLER_69_281 VGND VGND VPWR VPWR sky130_fd_sc_hd__decap_3
XFILLER_17_307 VGND VGND VPWR VPWR sky130_fd_sc_hd__fill_1
XFILLER_29_167 VGND VGND VPWR VPWR sky130_fd_sc_hd__fill_1
XFILLER_57_465 VGND VGND VPWR VPWR sky130_fd_sc_hd__decap_3
XFILLER_84_262 VGND VGND VPWR VPWR sky130_fd_sc_hd__decap_3
XTAP_TAPCELL_ROW_4_299 VGND VPWR sky130_fd_sc_hd__tapvpwrvgnd_1
XFILLER_17_329 VGND VGND VPWR VPWR sky130_fd_sc_hd__decap_3
XFILLER_38_690 VGND VGND VPWR VPWR sky130_fd_sc_hd__fill_1
XFILLER_45_638 VGND VGND VPWR VPWR sky130_fd_sc_hd__decap_3
XFILLER_111_30 VGND VGND VPWR VPWR sky130_fd_sc_hd__decap_3
XFILLER_25_340 VGND VGND VPWR VPWR sky130_fd_sc_hd__fill_1
XFILLER_60_619 VGND VGND VPWR VPWR sky130_fd_sc_hd__decap_3
XFILLER_111_63 VGND VGND VPWR VPWR sky130_fd_sc_hd__decap_3
XFILLER_53_671 VGND VGND VPWR VPWR sky130_fd_sc_hd__fill_1
XFILLER_53_682 VGND VGND VPWR VPWR sky130_fd_sc_hd__decap_3
XTAP_TAPCELL_ROW_84_1263 VGND VPWR sky130_fd_sc_hd__tapvpwrvgnd_1
XFILLER_13_546 VGND VGND VPWR VPWR sky130_fd_sc_hd__decap_3
XTAP_TAPCELL_ROW_23_530 VGND VPWR sky130_fd_sc_hd__tapvpwrvgnd_1
XFILLER_9_517 VGND VGND VPWR VPWR sky130_fd_sc_hd__decap_3
XFILLER_13_579 VGND VGND VPWR VPWR sky130_fd_sc_hd__decap_3
XFILLER_40_365 VGND VGND VPWR VPWR sky130_fd_sc_hd__fill_1
XFILLER_40_387 VGND VGND VPWR VPWR sky130_fd_sc_hd__decap_3
XFILLER_71_78 VGND VGND VPWR VPWR sky130_fd_sc_hd__decap_3
XTAP_TAPCELL_ROW_51_861 VGND VPWR sky130_fd_sc_hd__tapvpwrvgnd_1
XFILLER_107_662 VGND VGND VPWR VPWR sky130_fd_sc_hd__decap_3
XFILLER_107_673 VGND VGND VPWR VPWR sky130_fd_sc_hd__decap_3
XFILLER_4_244 VGND VGND VPWR VPWR sky130_fd_sc_hd__decap_3
XFILLER_4_288 VGND VGND VPWR VPWR sky130_fd_sc_hd__decap_3
XTAP_TAPCELL_ROW_95_1392 VGND VPWR sky130_fd_sc_hd__tapvpwrvgnd_1
XFILLER_95_505 VGND VGND VPWR VPWR sky130_fd_sc_hd__decap_3
XFILLER_95_538 VGND VGND VPWR VPWR sky130_fd_sc_hd__decap_3
XFILLER_0_483 VGND VGND VPWR VPWR sky130_fd_sc_hd__decap_3
XFILLER_48_443 VGND VGND VPWR VPWR sky130_fd_sc_hd__decap_3
XFILLER_36_616 VGND VGND VPWR VPWR sky130_fd_sc_hd__decap_3
XTAP_TAPCELL_ROW_59_961 VGND VPWR sky130_fd_sc_hd__tapvpwrvgnd_1
XFILLER_75_284 VGND VGND VPWR VPWR sky130_fd_sc_hd__decap_3
Xplace402 _4534_/S VGND VGND VPWR VPWR _4300_/B sky130_fd_sc_hd__buf_2
Xplace413 _4338_/B1 VGND VGND VPWR VPWR _4346_/B1 sky130_fd_sc_hd__buf_2
XFILLER_44_660 VGND VGND VPWR VPWR sky130_fd_sc_hd__decap_3
XFILLER_63_468 VGND VGND VPWR VPWR sky130_fd_sc_hd__decap_3
Xplace424 _3975_/S VGND VGND VPWR VPWR _3968_/S sky130_fd_sc_hd__buf_2
Xplace435 _3341_/A VGND VGND VPWR VPWR _5156_/S sky130_fd_sc_hd__buf_2
Xplace446 _3332_/B VGND VGND VPWR VPWR _4284_/A2 sky130_fd_sc_hd__buf_2
Xplace457 _3331_/B VGND VGND VPWR VPWR _5129_/B sky130_fd_sc_hd__buf_2
XFILLER_31_321 VGND VGND VPWR VPWR sky130_fd_sc_hd__decap_3
X_3880_ _3714_/X _3877_/X _3879_/X _3735_/X VGND VGND VPWR VPWR _3880_/X sky130_fd_sc_hd__a22o_2
XFILLER_31_365 VGND VGND VPWR VPWR sky130_fd_sc_hd__decap_3
XFILLER_8_572 VGND VGND VPWR VPWR sky130_fd_sc_hd__decap_3
X_4501_ _4501_/A0 _7297_/Q _4505_/S VGND VGND VPWR VPWR _7329_/D sky130_fd_sc_hd__mux2_2
X_7220_ _7349_/CLK _7220_/D _6500_/Y VGND VGND VPWR VPWR _7220_/Q sky130_fd_sc_hd__dfrtp_2
X_4432_ _7079_/Q _4102_/B _4432_/B1 _4431_/X VGND VGND VPWR VPWR _4440_/A sky130_fd_sc_hd__o211ai_2
XFILLER_113_632 VGND VGND VPWR VPWR sky130_fd_sc_hd__decap_3
X_7151_ _7311_/CLK _7151_/D _6431_/Y VGND VGND VPWR VPWR _7151_/Q sky130_fd_sc_hd__dfrtp_2
X_4363_ _4619_/B VGND VGND VPWR VPWR _4369_/A sky130_fd_sc_hd__inv_2
XFILLER_113_665 VGND VGND VPWR VPWR sky130_fd_sc_hd__decap_3
XFILLER_113_676 VGND VGND VPWR VPWR sky130_fd_sc_hd__decap_3
X_7082_ _7404_/CLK _7082_/D _6362_/Y VGND VGND VPWR VPWR _7082_/Q sky130_fd_sc_hd__dfrtp_2
X_4294_ _4294_/A _4612_/B VGND VGND VPWR VPWR _5113_/A sky130_fd_sc_hd__xor2_2
X_3314_ _4467_/A _4467_/B VGND VGND VPWR VPWR _5647_/A sky130_fd_sc_hd__or2_2
XFILLER_98_365 VGND VGND VPWR VPWR sky130_fd_sc_hd__decap_3
XFILLER_98_354 VGND VGND VPWR VPWR sky130_fd_sc_hd__fill_1
XFILLER_100_315 VGND VGND VPWR VPWR sky130_fd_sc_hd__decap_3
XFILLER_58_218 VGND VGND VPWR VPWR sky130_fd_sc_hd__decap_3
XFILLER_86_527 VGND VGND VPWR VPWR sky130_fd_sc_hd__decap_3
XFILLER_98_398 VGND VGND VPWR VPWR sky130_fd_sc_hd__decap_3
XFILLER_39_432 VGND VGND VPWR VPWR sky130_fd_sc_hd__decap_3
XFILLER_39_465 VGND VGND VPWR VPWR sky130_fd_sc_hd__decap_3
XFILLER_54_402 VGND VGND VPWR VPWR sky130_fd_sc_hd__decap_3
XFILLER_66_251 VGND VGND VPWR VPWR sky130_fd_sc_hd__fill_1
XFILLER_66_262 VGND VGND VPWR VPWR sky130_fd_sc_hd__decap_3
XFILLER_94_560 VGND VGND VPWR VPWR sky130_fd_sc_hd__decap_3
XFILLER_26_126 VGND VGND VPWR VPWR sky130_fd_sc_hd__fill_1
XFILLER_27_638 VGND VGND VPWR VPWR sky130_fd_sc_hd__decap_3
XFILLER_66_284 VGND VGND VPWR VPWR sky130_fd_sc_hd__decap_3
XTAP_TAPCELL_ROW_1_258 VGND VPWR sky130_fd_sc_hd__tapvpwrvgnd_1
XTAP_TAPCELL_ROW_107_1539 VGND VPWR sky130_fd_sc_hd__tapvpwrvgnd_1
XFILLER_26_159 VGND VGND VPWR VPWR sky130_fd_sc_hd__decap_3
XFILLER_42_619 VGND VGND VPWR VPWR sky130_fd_sc_hd__decap_3
XFILLER_81_243 VGND VGND VPWR VPWR sky130_fd_sc_hd__decap_3
X_6935_ _6941_/CLK _6935_/D VGND VGND VPWR VPWR _6935_/Q sky130_fd_sc_hd__dfxtp_2
XTAP_TAPCELL_ROW_1_269 VGND VPWR sky130_fd_sc_hd__tapvpwrvgnd_1
XFILLER_35_671 VGND VGND VPWR VPWR sky130_fd_sc_hd__fill_1
XFILLER_35_682 VGND VGND VPWR VPWR sky130_fd_sc_hd__decap_3
XFILLER_81_287 VGND VGND VPWR VPWR sky130_fd_sc_hd__decap_3
XTAP_TAPCELL_ROW_37_699 VGND VPWR sky130_fd_sc_hd__tapvpwrvgnd_1
XFILLER_34_192 VGND VGND VPWR VPWR sky130_fd_sc_hd__decap_3
X_6866_ _7378_/CLK _6866_/D VGND VGND VPWR VPWR _6866_/Q sky130_fd_sc_hd__dfxtp_2
XFILLER_22_365 VGND VGND VPWR VPWR sky130_fd_sc_hd__decap_3
XFILLER_50_663 VGND VGND VPWR VPWR sky130_fd_sc_hd__decap_3
X_6797_ _6941_/CLK _6797_/D VGND VGND VPWR VPWR _6797_/Q sky130_fd_sc_hd__dfxtp_2
XFILLER_41_37 VGND VGND VPWR VPWR sky130_fd_sc_hd__fill_2
XFILLER_108_415 VGND VGND VPWR VPWR sky130_fd_sc_hd__decap_3
XFILLER_108_448 VGND VGND VPWR VPWR sky130_fd_sc_hd__decap_3
XFILLER_104_610 VGND VGND VPWR VPWR sky130_fd_sc_hd__decap_3
XFILLER_1_225 VGND VGND VPWR VPWR sky130_fd_sc_hd__decap_3
X_7349_ _7349_/CLK _7349_/D _6629_/Y VGND VGND VPWR VPWR _7349_/Q sky130_fd_sc_hd__dfrtp_2
XTAP_TAPCELL_ROW_9_358 VGND VPWR sky130_fd_sc_hd__tapvpwrvgnd_1
XFILLER_104_643 VGND VGND VPWR VPWR sky130_fd_sc_hd__fill_1
XFILLER_104_654 VGND VGND VPWR VPWR sky130_fd_sc_hd__decap_3
XFILLER_77_505 VGND VGND VPWR VPWR sky130_fd_sc_hd__decap_3
XFILLER_89_365 VGND VGND VPWR VPWR sky130_fd_sc_hd__decap_3
Xhold583 _6856_/Q VGND VGND VPWR VPWR _6856_/D sky130_fd_sc_hd__dlygate4sd3_1
Xhold594 _6745_/Q VGND VGND VPWR VPWR _6745_/D sky130_fd_sc_hd__dlygate4sd3_1
XFILLER_103_175 VGND VGND VPWR VPWR sky130_fd_sc_hd__decap_3
XFILLER_104_687 VGND VGND VPWR VPWR sky130_fd_sc_hd__decap_3
XFILLER_106_41 VGND VGND VPWR VPWR sky130_fd_sc_hd__decap_3
XFILLER_49_218 VGND VGND VPWR VPWR sky130_fd_sc_hd__fill_1
XFILLER_106_96 VGND VGND VPWR VPWR sky130_fd_sc_hd__decap_3
XFILLER_66_12 VGND VGND VPWR VPWR sky130_fd_sc_hd__decap_3
XFILLER_77_549 VGND VGND VPWR VPWR sky130_fd_sc_hd__decap_3
XFILLER_18_616 VGND VGND VPWR VPWR sky130_fd_sc_hd__decap_3
XFILLER_17_104 VGND VGND VPWR VPWR sky130_fd_sc_hd__decap_3
XFILLER_45_446 VGND VGND VPWR VPWR sky130_fd_sc_hd__fill_2
XFILLER_85_582 VGND VGND VPWR VPWR sky130_fd_sc_hd__decap_3
XTAP_TAPCELL_ROW_56_920 VGND VPWR sky130_fd_sc_hd__tapvpwrvgnd_1
XFILLER_26_660 VGND VGND VPWR VPWR sky130_fd_sc_hd__decap_3
XFILLER_60_427 VGND VGND VPWR VPWR sky130_fd_sc_hd__decap_3
XFILLER_72_265 VGND VGND VPWR VPWR sky130_fd_sc_hd__decap_3
XFILLER_41_641 VGND VGND VPWR VPWR sky130_fd_sc_hd__decap_3
XFILLER_82_99 VGND VGND VPWR VPWR sky130_fd_sc_hd__decap_3
XFILLER_41_685 VGND VGND VPWR VPWR sky130_fd_sc_hd__decap_3
XFILLER_13_387 VGND VGND VPWR VPWR sky130_fd_sc_hd__decap_3
XFILLER_40_195 VGND VGND VPWR VPWR sky130_fd_sc_hd__fill_1
XTAP_TAPCELL_ROW_97_1421 VGND VPWR sky130_fd_sc_hd__tapvpwrvgnd_1
XTAP_TAPCELL_ROW_97_1410 VGND VPWR sky130_fd_sc_hd__tapvpwrvgnd_1
XFILLER_5_520 VGND VGND VPWR VPWR sky130_fd_sc_hd__decap_3
XFILLER_63_9 VGND VGND VPWR VPWR sky130_fd_sc_hd__decap_3
XFILLER_114_407 VGND VGND VPWR VPWR sky130_fd_sc_hd__decap_3
XFILLER_5_553 VGND VGND VPWR VPWR sky130_fd_sc_hd__decap_3
XFILLER_5_564 VGND VGND VPWR VPWR sky130_fd_sc_hd__decap_3
XFILLER_99_107 VGND VGND VPWR VPWR sky130_fd_sc_hd__decap_3
XFILLER_107_470 VGND VGND VPWR VPWR sky130_fd_sc_hd__decap_3
XFILLER_5_597 VGND VGND VPWR VPWR sky130_fd_sc_hd__decap_3
XFILLER_110_613 VGND VGND VPWR VPWR sky130_fd_sc_hd__decap_3
XFILLER_110_657 VGND VGND VPWR VPWR sky130_fd_sc_hd__decap_3
XFILLER_48_262 VGND VGND VPWR VPWR sky130_fd_sc_hd__decap_3
XFILLER_76_560 VGND VGND VPWR VPWR sky130_fd_sc_hd__decap_3
XFILLER_95_368 VGND VGND VPWR VPWR sky130_fd_sc_hd__fill_1
XFILLER_36_413 VGND VGND VPWR VPWR sky130_fd_sc_hd__decap_3
XFILLER_48_284 VGND VGND VPWR VPWR sky130_fd_sc_hd__decap_3
XFILLER_63_210 VGND VGND VPWR VPWR sky130_fd_sc_hd__decap_3
XFILLER_24_619 VGND VGND VPWR VPWR sky130_fd_sc_hd__decap_3
XFILLER_36_468 VGND VGND VPWR VPWR sky130_fd_sc_hd__fill_1
XFILLER_63_243 VGND VGND VPWR VPWR sky130_fd_sc_hd__decap_3
XFILLER_91_552 VGND VGND VPWR VPWR sky130_fd_sc_hd__decap_3
XFILLER_17_671 VGND VGND VPWR VPWR sky130_fd_sc_hd__fill_1
XFILLER_17_682 VGND VGND VPWR VPWR sky130_fd_sc_hd__decap_3
XFILLER_51_427 VGND VGND VPWR VPWR sky130_fd_sc_hd__decap_3
XFILLER_91_585 VGND VGND VPWR VPWR sky130_fd_sc_hd__decap_3
X_4981_ _6992_/Q _5001_/A VGND VGND VPWR VPWR _6992_/D sky130_fd_sc_hd__xor2_2
XFILLER_16_181 VGND VGND VPWR VPWR sky130_fd_sc_hd__decap_3
Xplace298 _3903_/A2 VGND VGND VPWR VPWR _3926_/B1 sky130_fd_sc_hd__buf_2
Xplace287 _3878_/A2 VGND VGND VPWR VPWR _3893_/B1 sky130_fd_sc_hd__buf_2
Xplace276 _3665_/X VGND VGND VPWR VPWR _3892_/B1 sky130_fd_sc_hd__buf_2
X_6720_ _6970_/CLK _6720_/D VGND VGND VPWR VPWR _6720_/Q sky130_fd_sc_hd__dfxtp_2
XTAP_TAPCELL_ROW_34_658 VGND VPWR sky130_fd_sc_hd__tapvpwrvgnd_1
XFILLER_32_663 VGND VGND VPWR VPWR sky130_fd_sc_hd__decap_3
X_6651_ _6651_/A VGND VGND VPWR VPWR _6651_/Y sky130_fd_sc_hd__inv_2
X_3863_ _6697_/Q _3903_/B1 _3922_/B1 _6875_/Q _3862_/X VGND VGND VPWR VPWR _3863_/X
+ sky130_fd_sc_hd__a221o_2
X_6582_ _6582_/A VGND VGND VPWR VPWR _6582_/Y sky130_fd_sc_hd__inv_2
X_5602_ _5602_/A _5634_/B VGND VGND VPWR VPWR _7026_/D sky130_fd_sc_hd__and2_2
X_3794_ _6774_/Q _3879_/A2 _3879_/B1 _6762_/Q _3793_/X VGND VGND VPWR VPWR _3794_/X
+ sky130_fd_sc_hd__a221o_2
XFILLER_11_29 VGND VGND VPWR VPWR sky130_fd_sc_hd__fill_2
X_7203_ _7368_/CLK _7203_/D _6483_/Y VGND VGND VPWR VPWR _7203_/Q sky130_fd_sc_hd__dfrtp_2
X_4415_ _7400_/Q _4419_/B1 _4434_/B1 _7144_/Q _4414_/X VGND VGND VPWR VPWR _4415_/X
+ sky130_fd_sc_hd__a221o_2
X_7134_ _7364_/CLK _7134_/D _6414_/Y VGND VGND VPWR VPWR _7134_/Q sky130_fd_sc_hd__dfrtp_2
X_4346_ _7321_/Q _3975_/S _4346_/B1 _7353_/Q VGND VGND VPWR VPWR _4346_/X sky130_fd_sc_hd__a22o_2
XFILLER_99_641 VGND VGND VPWR VPWR sky130_fd_sc_hd__decap_3
XFILLER_100_101 VGND VGND VPWR VPWR sky130_fd_sc_hd__fill_2
XFILLER_113_473 VGND VGND VPWR VPWR sky130_fd_sc_hd__decap_3
XFILLER_59_505 VGND VGND VPWR VPWR sky130_fd_sc_hd__decap_3
XTAP_TAPCELL_ROW_6_328 VGND VPWR sky130_fd_sc_hd__tapvpwrvgnd_1
XFILLER_99_685 VGND VGND VPWR VPWR sky130_fd_sc_hd__decap_3
XFILLER_100_123 VGND VGND VPWR VPWR sky130_fd_sc_hd__decap_3
XFILLER_101_635 VGND VGND VPWR VPWR sky130_fd_sc_hd__decap_3
X_7065_ _7392_/CLK _7065_/D _6345_/Y VGND VGND VPWR VPWR _7065_/Q sky130_fd_sc_hd__dfrtp_2
X_4277_ _5003_/A _4987_/A VGND VGND VPWR VPWR _4277_/Y sky130_fd_sc_hd__nor2_2
XFILLER_101_668 VGND VGND VPWR VPWR sky130_fd_sc_hd__decap_3
XFILLER_101_679 VGND VGND VPWR VPWR sky130_fd_sc_hd__decap_3
XFILLER_39_251 VGND VGND VPWR VPWR sky130_fd_sc_hd__decap_3
XFILLER_100_178 VGND VGND VPWR VPWR sky130_fd_sc_hd__decap_3
XFILLER_54_221 VGND VGND VPWR VPWR sky130_fd_sc_hd__fill_2
XFILLER_67_582 VGND VGND VPWR VPWR sky130_fd_sc_hd__decap_3
XFILLER_54_243 VGND VGND VPWR VPWR sky130_fd_sc_hd__decap_3
XFILLER_82_563 VGND VGND VPWR VPWR sky130_fd_sc_hd__decap_3
XFILLER_14_107 VGND VGND VPWR VPWR sky130_fd_sc_hd__decap_3
XTAP_TAPCELL_ROW_68_1066 VGND VPWR sky130_fd_sc_hd__tapvpwrvgnd_1
XFILLER_23_641 VGND VGND VPWR VPWR sky130_fd_sc_hd__decap_3
Xclkbuf_leaf_34_clk clkload1/A VGND VGND VPWR VPWR _7349_/CLK sky130_fd_sc_hd__clkbuf_16
X_6918_ _6968_/CLK _6918_/D VGND VGND VPWR VPWR _6918_/Q sky130_fd_sc_hd__dfxtp_2
XTAP_TAPCELL_ROW_81_1222 VGND VPWR sky130_fd_sc_hd__tapvpwrvgnd_1
XFILLER_23_685 VGND VGND VPWR VPWR sky130_fd_sc_hd__decap_3
X_6849_ _7378_/CLK _6849_/D VGND VGND VPWR VPWR _6849_/Q sky130_fd_sc_hd__dfxtp_2
XFILLER_10_324 VGND VGND VPWR VPWR sky130_fd_sc_hd__decap_3
XFILLER_10_368 VGND VGND VPWR VPWR sky130_fd_sc_hd__decap_3
XFILLER_6_306 VGND VGND VPWR VPWR sky130_fd_sc_hd__fill_2
XFILLER_108_212 VGND VGND VPWR VPWR sky130_fd_sc_hd__decap_3
XFILLER_6_328 VGND VGND VPWR VPWR sky130_fd_sc_hd__decap_3
XFILLER_108_267 VGND VGND VPWR VPWR sky130_fd_sc_hd__decap_3
XFILLER_2_501 VGND VGND VPWR VPWR sky130_fd_sc_hd__decap_3
XTAP_TAPCELL_ROW_79_1195 VGND VPWR sky130_fd_sc_hd__tapvpwrvgnd_1
XFILLER_2_545 VGND VGND VPWR VPWR sky130_fd_sc_hd__decap_3
XTAP_TAPCELL_ROW_92_1351 VGND VPWR sky130_fd_sc_hd__tapvpwrvgnd_1
XFILLER_2_578 VGND VGND VPWR VPWR sky130_fd_sc_hd__decap_3
XFILLER_2_589 VGND VGND VPWR VPWR sky130_fd_sc_hd__decap_3
XFILLER_104_495 VGND VGND VPWR VPWR sky130_fd_sc_hd__decap_3
XFILLER_77_324 VGND VGND VPWR VPWR sky130_fd_sc_hd__decap_3
XFILLER_89_195 VGND VGND VPWR VPWR sky130_fd_sc_hd__decap_3
XFILLER_65_508 VGND VGND VPWR VPWR sky130_fd_sc_hd__decap_3
XFILLER_77_368 VGND VGND VPWR VPWR sky130_fd_sc_hd__decap_3
XFILLER_92_305 VGND VGND VPWR VPWR sky130_fd_sc_hd__decap_3
XFILLER_100_690 VGND VGND VPWR VPWR sky130_fd_sc_hd__fill_1
XFILLER_18_402 VGND VGND VPWR VPWR sky130_fd_sc_hd__decap_3
XFILLER_18_424 VGND VGND VPWR VPWR sky130_fd_sc_hd__decap_3
XFILLER_58_571 VGND VGND VPWR VPWR sky130_fd_sc_hd__decap_3
XFILLER_93_21 VGND VGND VPWR VPWR sky130_fd_sc_hd__decap_3
Xhold1080 _7205_/Q VGND VGND VPWR VPWR _5249_/A0 sky130_fd_sc_hd__dlygate4sd3_1
Xhold1091 _7250_/Q VGND VGND VPWR VPWR _5140_/A0 sky130_fd_sc_hd__dlygate4sd3_1
XFILLER_73_585 VGND VGND VPWR VPWR sky130_fd_sc_hd__decap_3
XFILLER_60_224 VGND VGND VPWR VPWR sky130_fd_sc_hd__decap_3
Xclkbuf_leaf_25_clk clkload4/A VGND VGND VPWR VPWR _7364_/CLK sky130_fd_sc_hd__clkbuf_16
XFILLER_13_140 VGND VGND VPWR VPWR sky130_fd_sc_hd__decap_3
XFILLER_14_663 VGND VGND VPWR VPWR sky130_fd_sc_hd__decap_3
XFILLER_60_279 VGND VGND VPWR VPWR sky130_fd_sc_hd__decap_3
XFILLER_13_184 VGND VGND VPWR VPWR sky130_fd_sc_hd__fill_2
XTAP_TAPCELL_ROW_31_628 VGND VPWR sky130_fd_sc_hd__tapvpwrvgnd_1
XFILLER_9_166 VGND VGND VPWR VPWR sky130_fd_sc_hd__fill_2
XFILLER_61_6 VGND VGND VPWR VPWR sky130_fd_sc_hd__decap_3
XTAP_TAPCELL_ROW_11_385 VGND VPWR sky130_fd_sc_hd__tapvpwrvgnd_1
X_4200_ _4950_/A _4381_/A VGND VGND VPWR VPWR _4200_/X sky130_fd_sc_hd__or2_2
XFILLER_96_622 VGND VGND VPWR VPWR sky130_fd_sc_hd__decap_3
XFILLER_110_421 VGND VGND VPWR VPWR sky130_fd_sc_hd__decap_3
X_4131_ _7267_/Q _4401_/A2 _4128_/X _4130_/X VGND VGND VPWR VPWR _4131_/X sky130_fd_sc_hd__a211o_2
XFILLER_110_454 VGND VGND VPWR VPWR sky130_fd_sc_hd__decap_3
XFILLER_96_666 VGND VGND VPWR VPWR sky130_fd_sc_hd__decap_3
X_4062_ _7026_/Q _4437_/A2 _4390_/B1 _7212_/Q _4061_/X VGND VGND VPWR VPWR _4062_/X
+ sky130_fd_sc_hd__a221o_2
XTAP_TAPCELL_ROW_39_717 VGND VPWR sky130_fd_sc_hd__tapvpwrvgnd_1
XFILLER_110_498 VGND VGND VPWR VPWR sky130_fd_sc_hd__decap_3
XFILLER_49_582 VGND VGND VPWR VPWR sky130_fd_sc_hd__decap_3
XFILLER_83_349 VGND VGND VPWR VPWR sky130_fd_sc_hd__decap_3
XFILLER_64_563 VGND VGND VPWR VPWR sky130_fd_sc_hd__decap_3
XTAP_TAPCELL_ROW_19_474 VGND VPWR sky130_fd_sc_hd__tapvpwrvgnd_1
XFILLER_24_449 VGND VGND VPWR VPWR sky130_fd_sc_hd__decap_3
Xclkbuf_leaf_16_clk clkload3/A VGND VGND VPWR VPWR _7374_/CLK sky130_fd_sc_hd__clkbuf_16
X_4964_ _5092_/C _4961_/X _6994_/D _4997_/A1 VGND VGND VPWR VPWR _4964_/X sky130_fd_sc_hd__a22o_2
XTAP_TAPCELL_ROW_19_485 VGND VPWR sky130_fd_sc_hd__tapvpwrvgnd_1
XFILLER_51_257 VGND VGND VPWR VPWR sky130_fd_sc_hd__decap_3
X_6703_ _7378_/CLK _6703_/D VGND VGND VPWR VPWR _6703_/Q sky130_fd_sc_hd__dfxtp_2
X_3915_ _7378_/Q _3914_/X _5151_/A VGND VGND VPWR VPWR _7378_/D sky130_fd_sc_hd__mux2_2
XFILLER_20_622 VGND VGND VPWR VPWR sky130_fd_sc_hd__decap_3
X_4895_ _6997_/Q _5622_/B _4909_/B VGND VGND VPWR VPWR _4896_/B sky130_fd_sc_hd__a21o_2
XFILLER_20_666 VGND VGND VPWR VPWR sky130_fd_sc_hd__decap_3
X_6634_ _6636_/A VGND VGND VPWR VPWR _6634_/Y sky130_fd_sc_hd__inv_2
X_3846_ _6964_/Q _3661_/X _3886_/B1 _6952_/Q VGND VGND VPWR VPWR _3846_/X sky130_fd_sc_hd__a22o_2
X_6565_ _6566_/A VGND VGND VPWR VPWR _6565_/Y sky130_fd_sc_hd__inv_2
X_3777_ _6972_/Q _3893_/B1 _3887_/B1 _6722_/Q _3776_/X VGND VGND VPWR VPWR _3777_/X
+ sky130_fd_sc_hd__a221o_2
XFILLER_3_309 VGND VGND VPWR VPWR sky130_fd_sc_hd__decap_3
X_6496_ _6635_/A VGND VGND VPWR VPWR _6496_/Y sky130_fd_sc_hd__inv_2
XTAP_TAPCELL_ROW_115_1627 VGND VPWR sky130_fd_sc_hd__tapvpwrvgnd_1
XFILLER_87_600 VGND VGND VPWR VPWR sky130_fd_sc_hd__decap_3
Xoutput496 _3429_/A VGND VGND VPWR VPWR instruction_out[15] sky130_fd_sc_hd__clkdlybuf4s25_1
Xoutput485 _3735_/A VGND VGND VPWR VPWR alu_result_out[4] sky130_fd_sc_hd__clkdlybuf4s25_1
Xoutput474 _5655_/D VGND VGND VPWR VPWR alu_result_out[23] sky130_fd_sc_hd__clkdlybuf4s25_1
Xoutput463 _5023_/Y VGND VGND VPWR VPWR alu_result_out[13] sky130_fd_sc_hd__clkdlybuf4s25_1
XFILLER_101_410 VGND VGND VPWR VPWR sky130_fd_sc_hd__fill_2
XFILLER_101_421 VGND VGND VPWR VPWR sky130_fd_sc_hd__fill_1
XFILLER_113_281 VGND VGND VPWR VPWR sky130_fd_sc_hd__fill_1
XFILLER_59_324 VGND VGND VPWR VPWR sky130_fd_sc_hd__fill_1
XFILLER_59_335 VGND VGND VPWR VPWR sky130_fd_sc_hd__fill_1
XFILLER_59_346 VGND VGND VPWR VPWR sky130_fd_sc_hd__fill_1
XFILLER_87_644 VGND VGND VPWR VPWR sky130_fd_sc_hd__decap_3
X_7117_ _7372_/CLK _7117_/D _6397_/Y VGND VGND VPWR VPWR _7117_/Q sky130_fd_sc_hd__dfrtp_2
X_4329_ _4362_/C _4362_/A _4362_/B VGND VGND VPWR VPWR _4330_/B sky130_fd_sc_hd__and3b_2
XFILLER_101_443 VGND VGND VPWR VPWR sky130_fd_sc_hd__fill_2
XFILLER_87_688 VGND VGND VPWR VPWR sky130_fd_sc_hd__decap_3
X_7048_ _7395_/CLK _7048_/D _6328_/Y VGND VGND VPWR VPWR _7048_/Q sky130_fd_sc_hd__dfrtp_2
XFILLER_101_498 VGND VGND VPWR VPWR sky130_fd_sc_hd__decap_3
XFILLER_74_327 VGND VGND VPWR VPWR sky130_fd_sc_hd__decap_3
XFILLER_86_187 VGND VGND VPWR VPWR sky130_fd_sc_hd__decap_3
XPHY_EDGE_ROW_114_Right_114 VGND VGND VPWR VPWR sky130_fd_sc_hd__decap_3
XFILLER_27_232 VGND VGND VPWR VPWR sky130_fd_sc_hd__decap_3
XFILLER_15_427 VGND VGND VPWR VPWR sky130_fd_sc_hd__decap_3
XFILLER_55_585 VGND VGND VPWR VPWR sky130_fd_sc_hd__decap_3
XFILLER_63_24 VGND VGND VPWR VPWR sky130_fd_sc_hd__decap_3
XFILLER_82_360 VGND VGND VPWR VPWR sky130_fd_sc_hd__decap_3
XFILLER_27_287 VGND VGND VPWR VPWR sky130_fd_sc_hd__decap_3
XFILLER_63_57 VGND VGND VPWR VPWR sky130_fd_sc_hd__decap_3
XFILLER_70_533 VGND VGND VPWR VPWR sky130_fd_sc_hd__decap_3
XFILLER_70_555 VGND VGND VPWR VPWR sky130_fd_sc_hd__decap_3
XFILLER_11_600 VGND VGND VPWR VPWR sky130_fd_sc_hd__decap_3
XFILLER_63_68 VGND VGND VPWR VPWR sky130_fd_sc_hd__fill_1
XFILLER_23_482 VGND VGND VPWR VPWR sky130_fd_sc_hd__decap_3
XFILLER_11_644 VGND VGND VPWR VPWR sky130_fd_sc_hd__decap_3
XFILLER_7_615 VGND VGND VPWR VPWR sky130_fd_sc_hd__fill_1
XFILLER_109_532 VGND VGND VPWR VPWR sky130_fd_sc_hd__decap_3
XFILLER_11_688 VGND VGND VPWR VPWR sky130_fd_sc_hd__decap_3
XFILLER_7_626 VGND VGND VPWR VPWR sky130_fd_sc_hd__decap_3
XFILLER_109_576 VGND VGND VPWR VPWR sky130_fd_sc_hd__decap_3
XFILLER_12_61 VGND VGND VPWR VPWR sky130_fd_sc_hd__decap_3
XFILLER_7_659 VGND VGND VPWR VPWR sky130_fd_sc_hd__decap_3
Xwire568 _3371_/Y VGND VGND VPWR VPWR _3399_/A sky130_fd_sc_hd__clkdlybuf4s25_1
XFILLER_97_408 VGND VGND VPWR VPWR sky130_fd_sc_hd__decap_3
XFILLER_104_292 VGND VGND VPWR VPWR sky130_fd_sc_hd__decap_3
XFILLER_77_110 VGND VGND VPWR VPWR sky130_fd_sc_hd__fill_2
XFILLER_78_622 VGND VGND VPWR VPWR sky130_fd_sc_hd__decap_3
XFILLER_78_666 VGND VGND VPWR VPWR sky130_fd_sc_hd__decap_3
XFILLER_93_603 VGND VGND VPWR VPWR sky130_fd_sc_hd__decap_3
XFILLER_77_176 VGND VGND VPWR VPWR sky130_fd_sc_hd__decap_3
XFILLER_77_198 VGND VGND VPWR VPWR sky130_fd_sc_hd__decap_3
XFILLER_92_113 VGND VGND VPWR VPWR sky130_fd_sc_hd__decap_3
XFILLER_93_647 VGND VGND VPWR VPWR sky130_fd_sc_hd__decap_3
XFILLER_37_80 VGND VGND VPWR VPWR sky130_fd_sc_hd__decap_3
XFILLER_46_585 VGND VGND VPWR VPWR sky130_fd_sc_hd__decap_3
XFILLER_61_511 VGND VGND VPWR VPWR sky130_fd_sc_hd__decap_3
XFILLER_21_408 VGND VGND VPWR VPWR sky130_fd_sc_hd__decap_3
XFILLER_33_246 VGND VGND VPWR VPWR sky130_fd_sc_hd__decap_3
XFILLER_33_279 VGND VGND VPWR VPWR sky130_fd_sc_hd__fill_1
XFILLER_61_588 VGND VGND VPWR VPWR sky130_fd_sc_hd__decap_3
XTAP_TAPCELL_ROW_44_775 VGND VPWR sky130_fd_sc_hd__tapvpwrvgnd_1
XTAP_TAPCELL_ROW_16_444 VGND VPWR sky130_fd_sc_hd__tapvpwrvgnd_1
X_3700_ _6939_/Q _3768_/A2 _3918_/B1 _6803_/Q _3699_/X VGND VGND VPWR VPWR _3700_/X
+ sky130_fd_sc_hd__a221o_2
XFILLER_41_290 VGND VGND VPWR VPWR sky130_fd_sc_hd__decap_3
X_4680_ _4680_/A _5015_/B VGND VGND VPWR VPWR _5009_/A sky130_fd_sc_hd__nor2_2
X_3631_ _3630_/A _3630_/B _5146_/B1 VGND VGND VPWR VPWR _3631_/Y sky130_fd_sc_hd__o21ai_2
X_6350_ _6350_/A VGND VGND VPWR VPWR _6350_/Y sky130_fd_sc_hd__inv_2
X_3562_ _3562_/A _3562_/B _3561_/X VGND VGND VPWR VPWR _5362_/C sky130_fd_sc_hd__or3b_2
XFILLER_6_681 VGND VGND VPWR VPWR sky130_fd_sc_hd__decap_3
XFILLER_115_535 VGND VGND VPWR VPWR sky130_fd_sc_hd__decap_3
X_6281_ _6462_/A VGND VGND VPWR VPWR _6281_/Y sky130_fd_sc_hd__inv_2
X_3493_ _7087_/Q _3417_/X _3407_/X _7119_/Q VGND VGND VPWR VPWR _3493_/X sky130_fd_sc_hd__a22o_2
XFILLER_102_218 VGND VGND VPWR VPWR sky130_fd_sc_hd__decap_3
XFILLER_115_579 VGND VGND VPWR VPWR sky130_fd_sc_hd__decap_3
XFILLER_69_600 VGND VGND VPWR VPWR sky130_fd_sc_hd__decap_3
Xclkbuf_leaf_5_clk clkbuf_leaf_9_clk/A VGND VGND VPWR VPWR _6959_/CLK sky130_fd_sc_hd__clkbuf_16
X_5232_ _5232_/A0 _4716_/X _5256_/S VGND VGND VPWR VPWR _7214_/D sky130_fd_sc_hd__mux2_2
XFILLER_69_644 VGND VGND VPWR VPWR sky130_fd_sc_hd__decap_3
X_5163_ _5163_/A _5177_/B VGND VGND VPWR VPWR _7246_/D sky130_fd_sc_hd__and2_2
XFILLER_69_688 VGND VGND VPWR VPWR sky130_fd_sc_hd__decap_3
X_4114_ _7172_/Q _4348_/A2 _4420_/B1 _7140_/Q _4113_/X VGND VGND VPWR VPWR _4114_/X
+ sky130_fd_sc_hd__a221o_2
XTAP_TAPCELL_ROW_110_1568 VGND VPWR sky130_fd_sc_hd__tapvpwrvgnd_1
XFILLER_56_338 VGND VGND VPWR VPWR sky130_fd_sc_hd__decap_3
XFILLER_68_165 VGND VGND VPWR VPWR sky130_fd_sc_hd__decap_3
XFILLER_83_102 VGND VGND VPWR VPWR sky130_fd_sc_hd__fill_2
XFILLER_83_113 VGND VGND VPWR VPWR sky130_fd_sc_hd__decap_3
XFILLER_84_625 VGND VGND VPWR VPWR sky130_fd_sc_hd__decap_3
X_5094_ _5666_/A _6986_/D _5093_/X VGND VGND VPWR VPWR _5094_/X sky130_fd_sc_hd__a21o_2
XFILLER_84_669 VGND VGND VPWR VPWR sky130_fd_sc_hd__decap_3
X_4045_ _7085_/Q _4102_/B _4432_/B1 _4044_/X VGND VGND VPWR VPWR _4054_/A sky130_fd_sc_hd__o211a_2
XFILLER_37_585 VGND VGND VPWR VPWR sky130_fd_sc_hd__decap_3
XFILLER_52_511 VGND VGND VPWR VPWR sky130_fd_sc_hd__decap_3
XFILLER_64_371 VGND VGND VPWR VPWR sky130_fd_sc_hd__decap_3
XFILLER_71_319 VGND VGND VPWR VPWR sky130_fd_sc_hd__decap_3
XTAP_TAPCELL_ROW_65_1036 VGND VPWR sky130_fd_sc_hd__tapvpwrvgnd_1
XFILLER_12_408 VGND VGND VPWR VPWR sky130_fd_sc_hd__decap_3
XFILLER_24_246 VGND VGND VPWR VPWR sky130_fd_sc_hd__decap_3
XFILLER_24_268 VGND VGND VPWR VPWR sky130_fd_sc_hd__decap_3
XFILLER_52_577 VGND VGND VPWR VPWR sky130_fd_sc_hd__decap_3
X_4878_ _4997_/A1 _6999_/D _4870_/Y _4877_/X VGND VGND VPWR VPWR _4878_/X sky130_fd_sc_hd__a211o_2
XFILLER_20_452 VGND VGND VPWR VPWR sky130_fd_sc_hd__decap_3
X_6617_ _6617_/A VGND VGND VPWR VPWR _6617_/Y sky130_fd_sc_hd__inv_2
X_3829_ _6908_/Q _3926_/A2 _3883_/B1 _6900_/Q VGND VGND VPWR VPWR _3829_/X sky130_fd_sc_hd__a22o_2
XFILLER_4_607 VGND VGND VPWR VPWR sky130_fd_sc_hd__decap_3
XFILLER_106_513 VGND VGND VPWR VPWR sky130_fd_sc_hd__decap_3
X_6548_ _6642_/A VGND VGND VPWR VPWR _6548_/Y sky130_fd_sc_hd__inv_2
XFILLER_106_557 VGND VGND VPWR VPWR sky130_fd_sc_hd__decap_3
X_6479_ _6642_/A VGND VGND VPWR VPWR _6479_/Y sky130_fd_sc_hd__inv_2
XTAP_TAPCELL_ROW_76_1165 VGND VPWR sky130_fd_sc_hd__tapvpwrvgnd_1
XFILLER_59_154 VGND VGND VPWR VPWR sky130_fd_sc_hd__fill_2
XFILLER_75_603 VGND VGND VPWR VPWR sky130_fd_sc_hd__decap_3
XFILLER_87_452 VGND VGND VPWR VPWR sky130_fd_sc_hd__decap_3
XFILLER_114_41 VGND VGND VPWR VPWR sky130_fd_sc_hd__decap_3
XFILLER_47_305 VGND VGND VPWR VPWR sky130_fd_sc_hd__decap_3
XFILLER_75_647 VGND VGND VPWR VPWR sky130_fd_sc_hd__decap_3
XFILLER_114_74 VGND VGND VPWR VPWR sky130_fd_sc_hd__decap_3
XFILLER_114_85 VGND VGND VPWR VPWR sky130_fd_sc_hd__decap_3
XFILLER_59_198 VGND VGND VPWR VPWR sky130_fd_sc_hd__decap_3
XFILLER_74_124 VGND VGND VPWR VPWR sky130_fd_sc_hd__decap_3
XFILLER_74_157 VGND VGND VPWR VPWR sky130_fd_sc_hd__fill_1
XFILLER_74_23 VGND VGND VPWR VPWR sky130_fd_sc_hd__decap_3
XFILLER_28_563 VGND VGND VPWR VPWR sky130_fd_sc_hd__decap_3
XFILLER_43_511 VGND VGND VPWR VPWR sky130_fd_sc_hd__decap_3
XFILLER_74_45 VGND VGND VPWR VPWR sky130_fd_sc_hd__fill_1
XFILLER_90_628 VGND VGND VPWR VPWR sky130_fd_sc_hd__decap_3
XFILLER_55_393 VGND VGND VPWR VPWR sky130_fd_sc_hd__decap_3
XTAP_TAPCELL_ROW_87_1294 VGND VPWR sky130_fd_sc_hd__tapvpwrvgnd_1
XFILLER_15_246 VGND VGND VPWR VPWR sky130_fd_sc_hd__decap_3
XFILLER_15_268 VGND VGND VPWR VPWR sky130_fd_sc_hd__decap_3
XFILLER_43_588 VGND VGND VPWR VPWR sky130_fd_sc_hd__decap_3
XFILLER_90_44 VGND VGND VPWR VPWR sky130_fd_sc_hd__decap_3
XTAP_TAPCELL_ROW_13_403 VGND VPWR sky130_fd_sc_hd__tapvpwrvgnd_1
XFILLER_23_290 VGND VGND VPWR VPWR sky130_fd_sc_hd__decap_3
XFILLER_30_238 VGND VGND VPWR VPWR sky130_fd_sc_hd__fill_1
XTAP_TAPCELL_ROW_41_745 VGND VPWR sky130_fd_sc_hd__tapvpwrvgnd_1
XFILLER_11_452 VGND VGND VPWR VPWR sky130_fd_sc_hd__decap_3
XFILLER_7_412 VGND VGND VPWR VPWR sky130_fd_sc_hd__decap_3
XFILLER_99_53 VGND VGND VPWR VPWR sky130_fd_sc_hd__decap_3
XFILLER_112_516 VGND VGND VPWR VPWR sky130_fd_sc_hd__decap_3
XFILLER_3_662 VGND VGND VPWR VPWR sky130_fd_sc_hd__decap_3
XFILLER_3_673 VGND VGND VPWR VPWR sky130_fd_sc_hd__decap_3
XFILLER_65_113 VGND VGND VPWR VPWR sky130_fd_sc_hd__decap_3
XFILLER_66_625 VGND VGND VPWR VPWR sky130_fd_sc_hd__decap_3
XTAP_TAPCELL_ROW_49_834 VGND VPWR sky130_fd_sc_hd__tapvpwrvgnd_1
XFILLER_65_135 VGND VGND VPWR VPWR sky130_fd_sc_hd__decap_3
XFILLER_66_669 VGND VGND VPWR VPWR sky130_fd_sc_hd__decap_3
XFILLER_81_606 VGND VGND VPWR VPWR sky130_fd_sc_hd__decap_3
XTAP_TAPCELL_ROW_49_845 VGND VPWR sky130_fd_sc_hd__tapvpwrvgnd_1
XFILLER_19_552 VGND VGND VPWR VPWR sky130_fd_sc_hd__decap_3
XFILLER_53_308 VGND VGND VPWR VPWR sky130_fd_sc_hd__decap_3
XFILLER_65_157 VGND VGND VPWR VPWR sky130_fd_sc_hd__fill_2
XFILLER_81_617 VGND VGND VPWR VPWR sky130_fd_sc_hd__decap_3
XFILLER_19_585 VGND VGND VPWR VPWR sky130_fd_sc_hd__decap_3
XFILLER_34_533 VGND VGND VPWR VPWR sky130_fd_sc_hd__decap_3
XFILLER_80_127 VGND VGND VPWR VPWR sky130_fd_sc_hd__decap_3
XFILLER_34_577 VGND VGND VPWR VPWR sky130_fd_sc_hd__decap_3
XFILLER_73_190 VGND VGND VPWR VPWR sky130_fd_sc_hd__decap_3
X_4801_ _4801_/A _4801_/B VGND VGND VPWR VPWR _7003_/D sky130_fd_sc_hd__nor2_2
XFILLER_21_249 VGND VGND VPWR VPWR sky130_fd_sc_hd__decap_3
X_4663_ _4764_/B _4040_/B _4608_/Y _4659_/X _4662_/Y VGND VGND VPWR VPWR _5665_/A
+ sky130_fd_sc_hd__o32a_2
XFILLER_9_84 VGND VGND VPWR VPWR sky130_fd_sc_hd__decap_3
X_6402_ _6635_/A VGND VGND VPWR VPWR _6402_/Y sky130_fd_sc_hd__inv_2
X_3614_ _3614_/A _3614_/B VGND VGND VPWR VPWR _3746_/B sky130_fd_sc_hd__and2_2
X_7382_ clkload8/A _7382_/D _6662_/Y VGND VGND VPWR VPWR _7382_/Q sky130_fd_sc_hd__dfrtp_2
Xhold902 _7109_/Q VGND VGND VPWR VPWR _7109_/D sky130_fd_sc_hd__dlygate4sd3_1
Xhold913 _6712_/Q VGND VGND VPWR VPWR hold913/X sky130_fd_sc_hd__dlygate4sd3_1
Xhold924 _6689_/Q VGND VGND VPWR VPWR hold924/X sky130_fd_sc_hd__dlygate4sd3_1
Xhold946 _6711_/Q VGND VGND VPWR VPWR hold946/X sky130_fd_sc_hd__dlygate4sd3_1
Xhold935 _7393_/Q VGND VGND VPWR VPWR hold935/X sky130_fd_sc_hd__dlygate4sd3_1
X_6333_ _6649_/A VGND VGND VPWR VPWR _6333_/Y sky130_fd_sc_hd__inv_2
X_3545_ _3545_/A _3545_/B VGND VGND VPWR VPWR _3636_/A sky130_fd_sc_hd__nor2_2
XFILLER_103_505 VGND VGND VPWR VPWR sky130_fd_sc_hd__decap_3
Xhold979 _7404_/Q VGND VGND VPWR VPWR hold979/X sky130_fd_sc_hd__dlygate4sd3_1
Xhold968 _7014_/Q VGND VGND VPWR VPWR _5628_/A sky130_fd_sc_hd__dlygate4sd3_1
Xhold957 _6717_/Q VGND VGND VPWR VPWR hold957/X sky130_fd_sc_hd__dlygate4sd3_1
X_6264_ _6667_/A VGND VGND VPWR VPWR _6264_/Y sky130_fd_sc_hd__inv_2
X_3476_ _7056_/Q _4305_/B _3590_/A VGND VGND VPWR VPWR _3502_/B sky130_fd_sc_hd__o21ai_2
XFILLER_103_538 VGND VGND VPWR VPWR sky130_fd_sc_hd__decap_3
XFILLER_88_238 VGND VGND VPWR VPWR sky130_fd_sc_hd__fill_2
X_5215_ _5215_/A _5225_/B VGND VGND VPWR VPWR _7221_/D sky130_fd_sc_hd__and2_2
XFILLER_57_603 VGND VGND VPWR VPWR sky130_fd_sc_hd__decap_3
XFILLER_111_582 VGND VGND VPWR VPWR sky130_fd_sc_hd__decap_3
X_5146_ _5145_/A _3541_/X _5146_/B1 VGND VGND VPWR VPWR _5146_/Y sky130_fd_sc_hd__o21ai_2
XFILLER_29_349 VGND VGND VPWR VPWR sky130_fd_sc_hd__decap_3
XFILLER_57_647 VGND VGND VPWR VPWR sky130_fd_sc_hd__decap_3
X_5077_ _3904_/A _3863_/X _5658_/A VGND VGND VPWR VPWR _5077_/X sky130_fd_sc_hd__a21o_2
XFILLER_56_179 VGND VGND VPWR VPWR sky130_fd_sc_hd__fill_2
XFILLER_72_628 VGND VGND VPWR VPWR sky130_fd_sc_hd__decap_3
XFILLER_37_393 VGND VGND VPWR VPWR sky130_fd_sc_hd__fill_2
XFILLER_71_116 VGND VGND VPWR VPWR sky130_fd_sc_hd__decap_3
XFILLER_52_352 VGND VGND VPWR VPWR sky130_fd_sc_hd__decap_3
XFILLER_100_21 VGND VGND VPWR VPWR sky130_fd_sc_hd__decap_3
XFILLER_12_216 VGND VGND VPWR VPWR sky130_fd_sc_hd__decap_3
XFILLER_25_588 VGND VGND VPWR VPWR sky130_fd_sc_hd__decap_3
XFILLER_80_672 VGND VGND VPWR VPWR sky130_fd_sc_hd__decap_3
XFILLER_40_569 VGND VGND VPWR VPWR sky130_fd_sc_hd__decap_3
XFILLER_8_209 VGND VGND VPWR VPWR sky130_fd_sc_hd__fill_1
XFILLER_20_271 VGND VGND VPWR VPWR sky130_fd_sc_hd__decap_3
XFILLER_20_293 VGND VGND VPWR VPWR sky130_fd_sc_hd__decap_3
XFILLER_109_41 VGND VGND VPWR VPWR sky130_fd_sc_hd__decap_3
XFILLER_4_415 VGND VGND VPWR VPWR sky130_fd_sc_hd__fill_2
XFILLER_107_3 VGND VGND VPWR VPWR sky130_fd_sc_hd__decap_3
XFILLER_109_74 VGND VGND VPWR VPWR sky130_fd_sc_hd__fill_1
XFILLER_69_12 VGND VGND VPWR VPWR sky130_fd_sc_hd__decap_3
XFILLER_106_365 VGND VGND VPWR VPWR sky130_fd_sc_hd__decap_3
XFILLER_109_96 VGND VGND VPWR VPWR sky130_fd_sc_hd__decap_3
XFILLER_106_398 VGND VGND VPWR VPWR sky130_fd_sc_hd__decap_3
XFILLER_0_643 VGND VGND VPWR VPWR sky130_fd_sc_hd__fill_1
XFILLER_0_654 VGND VGND VPWR VPWR sky130_fd_sc_hd__decap_3
XFILLER_94_208 VGND VGND VPWR VPWR sky130_fd_sc_hd__fill_2
XFILLER_0_676 VGND VGND VPWR VPWR sky130_fd_sc_hd__decap_3
XFILLER_102_560 VGND VGND VPWR VPWR sky130_fd_sc_hd__decap_3
XFILLER_47_113 VGND VGND VPWR VPWR sky130_fd_sc_hd__fill_1
XFILLER_48_625 VGND VGND VPWR VPWR sky130_fd_sc_hd__decap_3
XFILLER_48_669 VGND VGND VPWR VPWR sky130_fd_sc_hd__decap_3
XFILLER_75_433 VGND VGND VPWR VPWR sky130_fd_sc_hd__decap_3
XTAP_TAPCELL_ROW_89_1323 VGND VPWR sky130_fd_sc_hd__tapvpwrvgnd_1
XFILLER_18_71 VGND VGND VPWR VPWR sky130_fd_sc_hd__fill_1
XFILLER_35_308 VGND VGND VPWR VPWR sky130_fd_sc_hd__decap_3
XFILLER_47_157 VGND VGND VPWR VPWR sky130_fd_sc_hd__fill_1
XFILLER_62_105 VGND VGND VPWR VPWR sky130_fd_sc_hd__decap_3
XFILLER_63_606 VGND VGND VPWR VPWR sky130_fd_sc_hd__decap_3
XFILLER_63_617 VGND VGND VPWR VPWR sky130_fd_sc_hd__decap_3
XFILLER_75_477 VGND VGND VPWR VPWR sky130_fd_sc_hd__decap_3
XTAP_TAPCELL_ROW_46_804 VGND VPWR sky130_fd_sc_hd__tapvpwrvgnd_1
XFILLER_16_533 VGND VGND VPWR VPWR sky130_fd_sc_hd__decap_3
XFILLER_16_566 VGND VGND VPWR VPWR sky130_fd_sc_hd__decap_3
XFILLER_71_650 VGND VGND VPWR VPWR sky130_fd_sc_hd__decap_3
XFILLER_70_160 VGND VGND VPWR VPWR sky130_fd_sc_hd__fill_1
XFILLER_70_171 VGND VGND VPWR VPWR sky130_fd_sc_hd__decap_3
XTAP_TAPCELL_ROW_26_561 VGND VPWR sky130_fd_sc_hd__tapvpwrvgnd_1
XFILLER_31_547 VGND VGND VPWR VPWR sky130_fd_sc_hd__fill_1
XFILLER_34_81 VGND VGND VPWR VPWR sky130_fd_sc_hd__decap_3
XFILLER_43_396 VGND VGND VPWR VPWR sky130_fd_sc_hd__fill_1
XFILLER_93_9 VGND VGND VPWR VPWR sky130_fd_sc_hd__decap_3
XFILLER_11_271 VGND VGND VPWR VPWR sky130_fd_sc_hd__decap_3
XFILLER_7_231 VGND VGND VPWR VPWR sky130_fd_sc_hd__decap_3
X_3330_ _5129_/A VGND VGND VPWR VPWR _3330_/Y sky130_fd_sc_hd__inv_2
XFILLER_112_324 VGND VGND VPWR VPWR sky130_fd_sc_hd__decap_3
XFILLER_3_481 VGND VGND VPWR VPWR sky130_fd_sc_hd__decap_3
XFILLER_98_536 VGND VGND VPWR VPWR sky130_fd_sc_hd__decap_3
XFILLER_98_525 VGND VGND VPWR VPWR sky130_fd_sc_hd__decap_3
XFILLER_112_368 VGND VGND VPWR VPWR sky130_fd_sc_hd__decap_3
X_5000_ _6991_/Q _5026_/A VGND VGND VPWR VPWR _5001_/B sky130_fd_sc_hd__nor2_2
XPHY_EDGE_ROW_0_Left_117 VGND VGND VPWR VPWR sky130_fd_sc_hd__decap_3
XFILLER_98_569 VGND VGND VPWR VPWR sky130_fd_sc_hd__decap_3
XFILLER_100_519 VGND VGND VPWR VPWR sky130_fd_sc_hd__decap_3
XFILLER_112_379 VGND VGND VPWR VPWR sky130_fd_sc_hd__decap_3
XFILLER_39_603 VGND VGND VPWR VPWR sky130_fd_sc_hd__decap_3
Xsingle_cycle_cpu VGND VGND VPWR VPWR single_cycle_cpu/HI instruction_out[19] sky130_fd_sc_hd__conb_1
XFILLER_39_647 VGND VGND VPWR VPWR sky130_fd_sc_hd__decap_3
XFILLER_54_628 VGND VGND VPWR VPWR sky130_fd_sc_hd__decap_3
XFILLER_66_477 VGND VGND VPWR VPWR sky130_fd_sc_hd__decap_3
XFILLER_19_393 VGND VGND VPWR VPWR sky130_fd_sc_hd__fill_2
X_6951_ _6978_/CLK _6951_/D VGND VGND VPWR VPWR _6951_/Q sky130_fd_sc_hd__dfxtp_2
X_6882_ clkload8/A _6882_/D VGND VGND VPWR VPWR _6882_/Q sky130_fd_sc_hd__dfxtp_2
XFILLER_61_160 VGND VGND VPWR VPWR sky130_fd_sc_hd__decap_3
XFILLER_62_672 VGND VGND VPWR VPWR sky130_fd_sc_hd__decap_3
XFILLER_14_29 VGND VGND VPWR VPWR sky130_fd_sc_hd__decap_3
XFILLER_22_547 VGND VGND VPWR VPWR sky130_fd_sc_hd__decap_3
X_5695_ _7353_/Q hold911/X _5703_/S VGND VGND VPWR VPWR _6697_/D sky130_fd_sc_hd__mux2_2
XFILLER_108_619 VGND VGND VPWR VPWR sky130_fd_sc_hd__decap_3
X_4646_ _4646_/A _4646_/B VGND VGND VPWR VPWR _4646_/Y sky130_fd_sc_hd__nand2_2
XFILLER_30_39 VGND VGND VPWR VPWR sky130_fd_sc_hd__decap_3
X_7365_ _7365_/CLK _7365_/D _6645_/Y VGND VGND VPWR VPWR _7365_/Q sky130_fd_sc_hd__dfrtp_2
Xhold710 _6935_/Q VGND VGND VPWR VPWR _6935_/D sky130_fd_sc_hd__dlygate4sd3_1
Xhold721 _6754_/Q VGND VGND VPWR VPWR _6754_/D sky130_fd_sc_hd__dlygate4sd3_1
X_4577_ _4577_/A _4577_/B VGND VGND VPWR VPWR _7292_/D sky130_fd_sc_hd__and2_2
XFILLER_115_140 VGND VGND VPWR VPWR sky130_fd_sc_hd__decap_3
Xhold732 _6801_/Q VGND VGND VPWR VPWR _6801_/D sky130_fd_sc_hd__dlygate4sd3_1
Xhold743 _6724_/Q VGND VGND VPWR VPWR _6724_/D sky130_fd_sc_hd__dlygate4sd3_1
Xhold754 _6957_/Q VGND VGND VPWR VPWR _6957_/D sky130_fd_sc_hd__dlygate4sd3_1
X_6316_ _6624_/A VGND VGND VPWR VPWR _6316_/Y sky130_fd_sc_hd__inv_2
XFILLER_103_302 VGND VGND VPWR VPWR sky130_fd_sc_hd__decap_3
XFILLER_115_162 VGND VGND VPWR VPWR sky130_fd_sc_hd__decap_3
XFILLER_115_184 VGND VGND VPWR VPWR sky130_fd_sc_hd__decap_3
XFILLER_89_547 VGND VGND VPWR VPWR sky130_fd_sc_hd__decap_3
X_7296_ _7328_/CLK _7296_/D _6576_/Y VGND VGND VPWR VPWR _7296_/Q sky130_fd_sc_hd__dfrtp_2
Xhold765 _6776_/Q VGND VGND VPWR VPWR _6776_/D sky130_fd_sc_hd__dlygate4sd3_1
Xhold776 _6877_/Q VGND VGND VPWR VPWR _6877_/D sky130_fd_sc_hd__dlygate4sd3_1
Xhold787 _6842_/Q VGND VGND VPWR VPWR _6842_/D sky130_fd_sc_hd__dlygate4sd3_1
X_3528_ _3528_/A _5118_/D VGND VGND VPWR VPWR _5659_/A sky130_fd_sc_hd__or2_2
XTAP_TAPCELL_ROW_73_1124 VGND VPWR sky130_fd_sc_hd__tapvpwrvgnd_1
XFILLER_103_335 VGND VGND VPWR VPWR sky130_fd_sc_hd__fill_1
XFILLER_103_346 VGND VGND VPWR VPWR sky130_fd_sc_hd__decap_3
Xhold798 _6791_/Q VGND VGND VPWR VPWR _6791_/D sky130_fd_sc_hd__dlygate4sd3_1
X_3459_ _7217_/Q _4349_/B1 _4348_/B1 _7121_/Q VGND VGND VPWR VPWR _3459_/X sky130_fd_sc_hd__a22o_2
XFILLER_69_260 VGND VGND VPWR VPWR sky130_fd_sc_hd__decap_3
XFILLER_76_219 VGND VGND VPWR VPWR sky130_fd_sc_hd__decap_3
XFILLER_97_591 VGND VGND VPWR VPWR sky130_fd_sc_hd__decap_3
X_5129_ _5129_/A _5129_/B VGND VGND VPWR VPWR _5130_/C sky130_fd_sc_hd__nor2_2
XFILLER_45_606 VGND VGND VPWR VPWR sky130_fd_sc_hd__decap_3
XFILLER_45_617 VGND VGND VPWR VPWR sky130_fd_sc_hd__decap_3
XFILLER_72_447 VGND VGND VPWR VPWR sky130_fd_sc_hd__decap_3
XFILLER_84_274 VGND VGND VPWR VPWR sky130_fd_sc_hd__decap_3
XFILLER_53_650 VGND VGND VPWR VPWR sky130_fd_sc_hd__decap_3
XFILLER_111_42 VGND VGND VPWR VPWR sky130_fd_sc_hd__decap_3
XFILLER_13_503 VGND VGND VPWR VPWR sky130_fd_sc_hd__fill_1
XTAP_TAPCELL_ROW_84_1264 VGND VPWR sky130_fd_sc_hd__tapvpwrvgnd_1
XFILLER_111_75 VGND VGND VPWR VPWR sky130_fd_sc_hd__decap_3
XFILLER_13_558 VGND VGND VPWR VPWR sky130_fd_sc_hd__fill_2
XFILLER_40_344 VGND VGND VPWR VPWR sky130_fd_sc_hd__decap_3
XTAP_TAPCELL_ROW_23_531 VGND VPWR sky130_fd_sc_hd__tapvpwrvgnd_1
XTAP_TAPCELL_ROW_51_862 VGND VPWR sky130_fd_sc_hd__tapvpwrvgnd_1
XFILLER_9_529 VGND VGND VPWR VPWR sky130_fd_sc_hd__decap_3
XFILLER_21_591 VGND VGND VPWR VPWR sky130_fd_sc_hd__decap_3
XFILLER_107_641 VGND VGND VPWR VPWR sky130_fd_sc_hd__decap_3
XFILLER_4_223 VGND VGND VPWR VPWR sky130_fd_sc_hd__decap_3
XFILLER_4_267 VGND VGND VPWR VPWR sky130_fd_sc_hd__decap_3
XFILLER_106_184 VGND VGND VPWR VPWR sky130_fd_sc_hd__decap_3
XFILLER_107_685 VGND VGND VPWR VPWR sky130_fd_sc_hd__decap_3
XFILLER_20_94 VGND VGND VPWR VPWR sky130_fd_sc_hd__decap_3
XTAP_TAPCELL_ROW_95_1393 VGND VPWR sky130_fd_sc_hd__tapvpwrvgnd_1
XFILLER_67_208 VGND VGND VPWR VPWR sky130_fd_sc_hd__decap_3
XFILLER_95_517 VGND VGND VPWR VPWR sky130_fd_sc_hd__decap_3
XFILLER_36_628 VGND VGND VPWR VPWR sky130_fd_sc_hd__decap_3
XFILLER_48_455 VGND VGND VPWR VPWR sky130_fd_sc_hd__decap_3
XFILLER_48_477 VGND VGND VPWR VPWR sky130_fd_sc_hd__decap_3
XFILLER_75_252 VGND VGND VPWR VPWR sky130_fd_sc_hd__fill_2
XTAP_TAPCELL_ROW_59_962 VGND VPWR sky130_fd_sc_hd__tapvpwrvgnd_1
XFILLER_90_200 VGND VGND VPWR VPWR sky130_fd_sc_hd__decap_3
Xplace403 _4517_/S VGND VGND VPWR VPWR _4505_/S sky130_fd_sc_hd__buf_2
XFILLER_51_609 VGND VGND VPWR VPWR sky130_fd_sc_hd__decap_3
XFILLER_90_233 VGND VGND VPWR VPWR sky130_fd_sc_hd__decap_3
Xplace414 _4338_/B1 VGND VGND VPWR VPWR _4278_/B1 sky130_fd_sc_hd__buf_2
Xplace425 _3996_/S VGND VGND VPWR VPWR _3975_/S sky130_fd_sc_hd__buf_2
Xplace436 _5117_/A VGND VGND VPWR VPWR _5595_/B sky130_fd_sc_hd__buf_2
Xplace447 _7010_/Q VGND VGND VPWR VPWR _7010_/D sky130_fd_sc_hd__buf_2
XPHY_EDGE_ROW_82_Left_199 VGND VGND VPWR VPWR sky130_fd_sc_hd__decap_3
XFILLER_16_374 VGND VGND VPWR VPWR sky130_fd_sc_hd__decap_3
XFILLER_44_672 VGND VGND VPWR VPWR sky130_fd_sc_hd__decap_3
XFILLER_90_277 VGND VGND VPWR VPWR sky130_fd_sc_hd__decap_3
Xplace458 _6979_/Q VGND VGND VPWR VPWR _3331_/B sky130_fd_sc_hd__buf_2
XFILLER_16_396 VGND VGND VPWR VPWR sky130_fd_sc_hd__decap_3
XFILLER_31_333 VGND VGND VPWR VPWR sky130_fd_sc_hd__decap_3
XFILLER_43_182 VGND VGND VPWR VPWR sky130_fd_sc_hd__fill_2
XFILLER_71_491 VGND VGND VPWR VPWR sky130_fd_sc_hd__decap_3
XFILLER_91_6 VGND VGND VPWR VPWR sky130_fd_sc_hd__decap_3
XFILLER_8_551 VGND VGND VPWR VPWR sky130_fd_sc_hd__decap_3
XANTENNA_1 _7363_/Q VGND VGND VPWR VPWR sky130_fd_sc_hd__diode_2
XFILLER_8_584 VGND VGND VPWR VPWR sky130_fd_sc_hd__decap_3
XFILLER_8_595 VGND VGND VPWR VPWR sky130_fd_sc_hd__decap_3
X_4431_ _7271_/Q _4437_/A2 _4428_/X _4430_/X VGND VGND VPWR VPWR _4431_/X sky130_fd_sc_hd__a211o_2
XFILLER_6_85 VGND VGND VPWR VPWR sky130_fd_sc_hd__decap_3
XFILLER_113_600 VGND VGND VPWR VPWR sky130_fd_sc_hd__decap_3
X_7150_ _7374_/CLK _7150_/D _6430_/Y VGND VGND VPWR VPWR _7150_/Q sky130_fd_sc_hd__dfrtp_2
X_4362_ _4362_/A _4362_/B _4362_/C VGND VGND VPWR VPWR _4362_/X sky130_fd_sc_hd__and3_2
XFILLER_113_644 VGND VGND VPWR VPWR sky130_fd_sc_hd__decap_3
X_7081_ _7372_/CLK _7081_/D _6361_/Y VGND VGND VPWR VPWR _7081_/Q sky130_fd_sc_hd__dfrtp_2
X_4293_ _4294_/A _4612_/B VGND VGND VPWR VPWR _4293_/X sky130_fd_sc_hd__and2b_2
X_3313_ _3561_/B _3313_/B _6981_/Q _6982_/Q VGND VGND VPWR VPWR _4467_/B sky130_fd_sc_hd__nand4b_4
XFILLER_100_305 VGND VGND VPWR VPWR sky130_fd_sc_hd__decap_3
XFILLER_113_688 VGND VGND VPWR VPWR sky130_fd_sc_hd__decap_3
XFILLER_86_539 VGND VGND VPWR VPWR sky130_fd_sc_hd__decap_3
XFILLER_100_327 VGND VGND VPWR VPWR sky130_fd_sc_hd__decap_3
XFILLER_79_591 VGND VGND VPWR VPWR sky130_fd_sc_hd__decap_3
XFILLER_27_606 VGND VGND VPWR VPWR sky130_fd_sc_hd__decap_3
XFILLER_27_617 VGND VGND VPWR VPWR sky130_fd_sc_hd__decap_3
XFILLER_39_477 VGND VGND VPWR VPWR sky130_fd_sc_hd__decap_3
XFILLER_66_230 VGND VGND VPWR VPWR sky130_fd_sc_hd__decap_3
XFILLER_94_572 VGND VGND VPWR VPWR sky130_fd_sc_hd__decap_3
XFILLER_54_425 VGND VGND VPWR VPWR sky130_fd_sc_hd__decap_3
XFILLER_66_274 VGND VGND VPWR VPWR sky130_fd_sc_hd__decap_3
XFILLER_66_296 VGND VGND VPWR VPWR sky130_fd_sc_hd__decap_3
XFILLER_81_211 VGND VGND VPWR VPWR sky130_fd_sc_hd__decap_3
XFILLER_26_138 VGND VGND VPWR VPWR sky130_fd_sc_hd__fill_2
XFILLER_35_650 VGND VGND VPWR VPWR sky130_fd_sc_hd__decap_3
X_6934_ _6943_/CLK _6934_/D VGND VGND VPWR VPWR _6934_/Q sky130_fd_sc_hd__dfxtp_2
XTAP_TAPCELL_ROW_1_259 VGND VPWR sky130_fd_sc_hd__tapvpwrvgnd_1
XFILLER_81_299 VGND VGND VPWR VPWR sky130_fd_sc_hd__decap_3
XFILLER_34_171 VGND VGND VPWR VPWR sky130_fd_sc_hd__decap_3
XFILLER_50_631 VGND VGND VPWR VPWR sky130_fd_sc_hd__decap_3
XFILLER_62_480 VGND VGND VPWR VPWR sky130_fd_sc_hd__decap_3
X_6865_ _6943_/CLK _6865_/D VGND VGND VPWR VPWR _6865_/Q sky130_fd_sc_hd__dfxtp_2
XFILLER_10_517 VGND VGND VPWR VPWR sky130_fd_sc_hd__decap_3
XFILLER_50_675 VGND VGND VPWR VPWR sky130_fd_sc_hd__decap_3
X_6796_ _7398_/CLK _6796_/D VGND VGND VPWR VPWR _6796_/Q sky130_fd_sc_hd__dfxtp_2
XFILLER_10_539 VGND VGND VPWR VPWR sky130_fd_sc_hd__decap_3
XFILLER_108_427 VGND VGND VPWR VPWR sky130_fd_sc_hd__decap_3
X_5678_ _7345_/Q hold924/X _5703_/S VGND VGND VPWR VPWR _6689_/D sky130_fd_sc_hd__mux2_2
X_4629_ _4629_/A _4629_/B VGND VGND VPWR VPWR _4629_/Y sky130_fd_sc_hd__nor2_2
XFILLER_104_622 VGND VGND VPWR VPWR sky130_fd_sc_hd__decap_3
XFILLER_116_460 VGND VGND VPWR VPWR sky130_fd_sc_hd__decap_3
XFILLER_1_204 VGND VGND VPWR VPWR sky130_fd_sc_hd__decap_3
XFILLER_1_215 VGND VGND VPWR VPWR sky130_fd_sc_hd__fill_2
X_7348_ _7350_/CLK _7348_/D _6628_/Y VGND VGND VPWR VPWR _7348_/Q sky130_fd_sc_hd__dfrtp_2
XFILLER_104_666 VGND VGND VPWR VPWR sky130_fd_sc_hd__decap_3
XFILLER_106_20 VGND VGND VPWR VPWR sky130_fd_sc_hd__decap_3
X_7279_ _7311_/CLK _7279_/D _6559_/Y VGND VGND VPWR VPWR _7279_/Q sky130_fd_sc_hd__dfrtp_2
Xhold584 _6912_/Q VGND VGND VPWR VPWR _6912_/D sky130_fd_sc_hd__dlygate4sd3_1
Xhold595 _6832_/Q VGND VGND VPWR VPWR _6832_/D sky130_fd_sc_hd__dlygate4sd3_1
XTAP_TAPCELL_ROW_9_359 VGND VPWR sky130_fd_sc_hd__tapvpwrvgnd_1
XFILLER_106_53 VGND VGND VPWR VPWR sky130_fd_sc_hd__decap_3
XFILLER_89_377 VGND VGND VPWR VPWR sky130_fd_sc_hd__decap_3
XFILLER_66_24 VGND VGND VPWR VPWR sky130_fd_sc_hd__decap_3
XFILLER_66_68 VGND VGND VPWR VPWR sky130_fd_sc_hd__decap_3
XFILLER_66_79 VGND VGND VPWR VPWR sky130_fd_sc_hd__decap_3
XFILLER_85_561 VGND VGND VPWR VPWR sky130_fd_sc_hd__decap_3
XFILLER_18_628 VGND VGND VPWR VPWR sky130_fd_sc_hd__decap_3
XFILLER_57_296 VGND VGND VPWR VPWR sky130_fd_sc_hd__decap_3
XFILLER_72_200 VGND VGND VPWR VPWR sky130_fd_sc_hd__decap_3
XFILLER_85_594 VGND VGND VPWR VPWR sky130_fd_sc_hd__decap_3
XTAP_TAPCELL_ROW_56_921 VGND VPWR sky130_fd_sc_hd__tapvpwrvgnd_1
XFILLER_33_609 VGND VGND VPWR VPWR sky130_fd_sc_hd__decap_3
XFILLER_45_469 VGND VGND VPWR VPWR sky130_fd_sc_hd__decap_3
XFILLER_72_233 VGND VGND VPWR VPWR sky130_fd_sc_hd__decap_3
XFILLER_26_672 VGND VGND VPWR VPWR sky130_fd_sc_hd__decap_3
XFILLER_60_406 VGND VGND VPWR VPWR sky130_fd_sc_hd__decap_3
XFILLER_13_311 VGND VGND VPWR VPWR sky130_fd_sc_hd__decap_3
XFILLER_41_620 VGND VGND VPWR VPWR sky130_fd_sc_hd__decap_3
XFILLER_13_355 VGND VGND VPWR VPWR sky130_fd_sc_hd__decap_3
XFILLER_40_141 VGND VGND VPWR VPWR sky130_fd_sc_hd__decap_3
XFILLER_41_653 VGND VGND VPWR VPWR sky130_fd_sc_hd__decap_3
XTAP_TAPCELL_ROW_97_1411 VGND VPWR sky130_fd_sc_hd__tapvpwrvgnd_1
XFILLER_5_532 VGND VGND VPWR VPWR sky130_fd_sc_hd__decap_3
XFILLER_31_93 VGND VGND VPWR VPWR sky130_fd_sc_hd__decap_3
XFILLER_56_9 VGND VGND VPWR VPWR sky130_fd_sc_hd__decap_3
XFILLER_107_482 VGND VGND VPWR VPWR sky130_fd_sc_hd__decap_3
XFILLER_114_419 VGND VGND VPWR VPWR sky130_fd_sc_hd__fill_1
XFILLER_5_576 VGND VGND VPWR VPWR sky130_fd_sc_hd__decap_3
XFILLER_110_625 VGND VGND VPWR VPWR sky130_fd_sc_hd__decap_3
XFILLER_0_270 VGND VGND VPWR VPWR sky130_fd_sc_hd__fill_1
XFILLER_0_281 VGND VGND VPWR VPWR sky130_fd_sc_hd__decap_3
XFILLER_95_325 VGND VGND VPWR VPWR sky130_fd_sc_hd__decap_3
XFILLER_110_669 VGND VGND VPWR VPWR sky130_fd_sc_hd__decap_3
XFILLER_48_241 VGND VGND VPWR VPWR sky130_fd_sc_hd__fill_2
XFILLER_83_509 VGND VGND VPWR VPWR sky130_fd_sc_hd__fill_1
XFILLER_48_296 VGND VGND VPWR VPWR sky130_fd_sc_hd__decap_3
XFILLER_76_572 VGND VGND VPWR VPWR sky130_fd_sc_hd__decap_3
XFILLER_91_520 VGND VGND VPWR VPWR sky130_fd_sc_hd__fill_2
XPHY_EDGE_ROW_90_Left_207 VGND VGND VPWR VPWR sky130_fd_sc_hd__decap_3
XFILLER_17_650 VGND VGND VPWR VPWR sky130_fd_sc_hd__decap_3
XFILLER_63_222 VGND VGND VPWR VPWR sky130_fd_sc_hd__fill_2
XFILLER_63_255 VGND VGND VPWR VPWR sky130_fd_sc_hd__decap_3
XFILLER_91_531 VGND VGND VPWR VPWR sky130_fd_sc_hd__decap_3
XFILLER_91_564 VGND VGND VPWR VPWR sky130_fd_sc_hd__decap_3
XFILLER_51_406 VGND VGND VPWR VPWR sky130_fd_sc_hd__decap_3
XFILLER_91_597 VGND VGND VPWR VPWR sky130_fd_sc_hd__decap_3
XFILLER_32_631 VGND VGND VPWR VPWR sky130_fd_sc_hd__decap_3
Xplace288 _5660_/B VGND VGND VPWR VPWR _3878_/A2 sky130_fd_sc_hd__buf_2
Xplace277 _3887_/B1 VGND VGND VPWR VPWR _3922_/B1 sky130_fd_sc_hd__buf_2
Xplace266 _4926_/Y VGND VGND VPWR VPWR _5656_/C sky130_fd_sc_hd__buf_2
X_3931_ _7374_/Q _4474_/A0 _3947_/S VGND VGND VPWR VPWR _7374_/D sky130_fd_sc_hd__mux2_2
XTAP_TAPCELL_ROW_34_659 VGND VPWR sky130_fd_sc_hd__tapvpwrvgnd_1
XFILLER_32_675 VGND VGND VPWR VPWR sky130_fd_sc_hd__decap_3
Xplace299 _3922_/A2 VGND VGND VPWR VPWR _3903_/A2 sky130_fd_sc_hd__buf_2
X_6650_ _6652_/A VGND VGND VPWR VPWR _6650_/Y sky130_fd_sc_hd__inv_2
X_3862_ _6923_/Q _3918_/A2 _3903_/A2 _6787_/Q VGND VGND VPWR VPWR _3862_/X sky130_fd_sc_hd__a22o_2
XFILLER_31_174 VGND VGND VPWR VPWR sky130_fd_sc_hd__decap_3
X_6581_ _6581_/A VGND VGND VPWR VPWR _6581_/Y sky130_fd_sc_hd__inv_2
X_3793_ _6756_/Q _3878_/A2 _3888_/B1 _6768_/Q VGND VGND VPWR VPWR _3793_/X sky130_fd_sc_hd__a22o_2
X_7202_ _7395_/CLK _7202_/D _6482_/Y VGND VGND VPWR VPWR _7202_/Q sky130_fd_sc_hd__dfrtp_2
X_5394_ _5394_/A0 _4964_/X _5409_/S VGND VGND VPWR VPWR _7136_/D sky130_fd_sc_hd__mux2_2
X_4414_ _7240_/Q _4414_/A2 _3954_/S _7208_/Q VGND VGND VPWR VPWR _4414_/X sky130_fd_sc_hd__a22o_2
XFILLER_99_620 VGND VGND VPWR VPWR sky130_fd_sc_hd__decap_3
XFILLER_113_441 VGND VGND VPWR VPWR sky130_fd_sc_hd__decap_3
X_7133_ _7364_/CLK _7133_/D _6413_/Y VGND VGND VPWR VPWR _7133_/Q sky130_fd_sc_hd__dfrtp_2
X_4345_ _4343_/X _4345_/B VGND VGND VPWR VPWR _5101_/B sky130_fd_sc_hd__nand2b_2
XFILLER_99_653 VGND VGND VPWR VPWR sky130_fd_sc_hd__decap_3
XFILLER_98_130 VGND VGND VPWR VPWR sky130_fd_sc_hd__fill_1
XFILLER_101_603 VGND VGND VPWR VPWR sky130_fd_sc_hd__decap_3
XFILLER_113_452 VGND VGND VPWR VPWR sky130_fd_sc_hd__decap_3
XFILLER_86_303 VGND VGND VPWR VPWR sky130_fd_sc_hd__decap_3
XTAP_TAPCELL_ROW_6_329 VGND VPWR sky130_fd_sc_hd__tapvpwrvgnd_1
XTAP_TAPCELL_ROW_6_318 VGND VPWR sky130_fd_sc_hd__tapvpwrvgnd_1
XFILLER_98_141 VGND VGND VPWR VPWR sky130_fd_sc_hd__fill_2
XFILLER_101_647 VGND VGND VPWR VPWR sky130_fd_sc_hd__decap_3
XFILLER_113_485 VGND VGND VPWR VPWR sky130_fd_sc_hd__decap_3
XFILLER_86_347 VGND VGND VPWR VPWR sky130_fd_sc_hd__decap_3
X_7064_ _7344_/CLK _7064_/D _6344_/Y VGND VGND VPWR VPWR _7064_/Q sky130_fd_sc_hd__dfrtp_2
XFILLER_100_135 VGND VGND VPWR VPWR sky130_fd_sc_hd__decap_3
XFILLER_39_230 VGND VGND VPWR VPWR sky130_fd_sc_hd__decap_3
XFILLER_67_561 VGND VGND VPWR VPWR sky130_fd_sc_hd__decap_3
XFILLER_39_263 VGND VGND VPWR VPWR sky130_fd_sc_hd__fill_1
XFILLER_67_594 VGND VGND VPWR VPWR sky130_fd_sc_hd__decap_3
XFILLER_15_609 VGND VGND VPWR VPWR sky130_fd_sc_hd__decap_3
XFILLER_27_436 VGND VGND VPWR VPWR sky130_fd_sc_hd__fill_1
XFILLER_27_447 VGND VGND VPWR VPWR sky130_fd_sc_hd__fill_1
XFILLER_27_458 VGND VGND VPWR VPWR sky130_fd_sc_hd__decap_3
XFILLER_82_531 VGND VGND VPWR VPWR sky130_fd_sc_hd__fill_1
XFILLER_82_542 VGND VGND VPWR VPWR sky130_fd_sc_hd__decap_3
XFILLER_14_119 VGND VGND VPWR VPWR sky130_fd_sc_hd__decap_3
XFILLER_82_575 VGND VGND VPWR VPWR sky130_fd_sc_hd__decap_3
XTAP_TAPCELL_ROW_68_1067 VGND VPWR sky130_fd_sc_hd__tapvpwrvgnd_1
XFILLER_23_620 VGND VGND VPWR VPWR sky130_fd_sc_hd__decap_3
XFILLER_35_480 VGND VGND VPWR VPWR sky130_fd_sc_hd__decap_3
XFILLER_42_439 VGND VGND VPWR VPWR sky130_fd_sc_hd__decap_3
X_6917_ _6954_/CLK _6917_/D VGND VGND VPWR VPWR _6917_/Q sky130_fd_sc_hd__dfxtp_2
XTAP_TAPCELL_ROW_81_1223 VGND VPWR sky130_fd_sc_hd__tapvpwrvgnd_1
XFILLER_22_141 VGND VGND VPWR VPWR sky130_fd_sc_hd__fill_1
XFILLER_23_653 VGND VGND VPWR VPWR sky130_fd_sc_hd__decap_3
X_6848_ _6970_/CLK _6848_/D VGND VGND VPWR VPWR _6848_/Q sky130_fd_sc_hd__dfxtp_2
XFILLER_10_358 VGND VGND VPWR VPWR sky130_fd_sc_hd__decap_3
X_6779_ _6943_/CLK _6779_/D VGND VGND VPWR VPWR _6779_/Q sky130_fd_sc_hd__dfxtp_2
XFILLER_108_279 VGND VGND VPWR VPWR sky130_fd_sc_hd__decap_3
XFILLER_2_513 VGND VGND VPWR VPWR sky130_fd_sc_hd__decap_3
XTAP_TAPCELL_ROW_79_1196 VGND VPWR sky130_fd_sc_hd__tapvpwrvgnd_1
XFILLER_116_290 VGND VGND VPWR VPWR sky130_fd_sc_hd__decap_3
XFILLER_2_557 VGND VGND VPWR VPWR sky130_fd_sc_hd__decap_3
XTAP_TAPCELL_ROW_92_1352 VGND VPWR sky130_fd_sc_hd__tapvpwrvgnd_1
XFILLER_104_463 VGND VGND VPWR VPWR sky130_fd_sc_hd__decap_3
XFILLER_77_347 VGND VGND VPWR VPWR sky130_fd_sc_hd__decap_3
XFILLER_45_211 VGND VGND VPWR VPWR sky130_fd_sc_hd__decap_3
XFILLER_58_583 VGND VGND VPWR VPWR sky130_fd_sc_hd__decap_3
XFILLER_18_469 VGND VGND VPWR VPWR sky130_fd_sc_hd__fill_1
XFILLER_85_391 VGND VGND VPWR VPWR sky130_fd_sc_hd__fill_1
Xhold1070 _7403_/Q VGND VGND VPWR VPWR _3693_/A0 sky130_fd_sc_hd__dlygate4sd3_1
Xhold1081 _7224_/Q VGND VGND VPWR VPWR _5209_/A sky130_fd_sc_hd__dlygate4sd3_1
Xhold1092 _7327_/Q VGND VGND VPWR VPWR _4505_/A0 sky130_fd_sc_hd__dlygate4sd3_1
XFILLER_45_255 VGND VGND VPWR VPWR sky130_fd_sc_hd__decap_3
XFILLER_45_266 VGND VGND VPWR VPWR sky130_fd_sc_hd__fill_1
XFILLER_60_203 VGND VGND VPWR VPWR sky130_fd_sc_hd__decap_3
XFILLER_73_564 VGND VGND VPWR VPWR sky130_fd_sc_hd__decap_3
XFILLER_93_88 VGND VGND VPWR VPWR sky130_fd_sc_hd__decap_3
XFILLER_14_631 VGND VGND VPWR VPWR sky130_fd_sc_hd__decap_3
XFILLER_26_480 VGND VGND VPWR VPWR sky130_fd_sc_hd__fill_2
XFILLER_26_93 VGND VGND VPWR VPWR sky130_fd_sc_hd__decap_3
XFILLER_60_236 VGND VGND VPWR VPWR sky130_fd_sc_hd__decap_3
XFILLER_73_597 VGND VGND VPWR VPWR sky130_fd_sc_hd__decap_3
XFILLER_14_675 VGND VGND VPWR VPWR sky130_fd_sc_hd__decap_3
XFILLER_41_461 VGND VGND VPWR VPWR sky130_fd_sc_hd__decap_3
XFILLER_41_494 VGND VGND VPWR VPWR sky130_fd_sc_hd__fill_1
XTAP_TAPCELL_ROW_31_629 VGND VPWR sky130_fd_sc_hd__tapvpwrvgnd_1
XTAP_TAPCELL_ROW_31_618 VGND VPWR sky130_fd_sc_hd__tapvpwrvgnd_1
XTAP_TAPCELL_ROW_11_386 VGND VPWR sky130_fd_sc_hd__tapvpwrvgnd_1
XFILLER_114_216 VGND VGND VPWR VPWR sky130_fd_sc_hd__fill_2
XFILLER_54_6 VGND VGND VPWR VPWR sky130_fd_sc_hd__decap_3
XFILLER_107_290 VGND VGND VPWR VPWR sky130_fd_sc_hd__fill_2
XFILLER_110_400 VGND VGND VPWR VPWR sky130_fd_sc_hd__decap_3
XFILLER_96_601 VGND VGND VPWR VPWR sky130_fd_sc_hd__decap_3
X_4130_ _7235_/Q _4421_/A2 _4459_/C1 _7171_/Q _4129_/X VGND VGND VPWR VPWR _4130_/X
+ sky130_fd_sc_hd__a221o_2
XFILLER_110_411 VGND VGND VPWR VPWR sky130_fd_sc_hd__decap_3
XFILLER_110_433 VGND VGND VPWR VPWR sky130_fd_sc_hd__decap_3
XFILLER_68_314 VGND VGND VPWR VPWR sky130_fd_sc_hd__fill_2
XFILLER_96_634 VGND VGND VPWR VPWR sky130_fd_sc_hd__decap_3
XFILLER_96_645 VGND VGND VPWR VPWR sky130_fd_sc_hd__decap_3
XFILLER_110_466 VGND VGND VPWR VPWR sky130_fd_sc_hd__decap_3
XFILLER_3_86 VGND VGND VPWR VPWR sky130_fd_sc_hd__fill_1
XFILLER_49_561 VGND VGND VPWR VPWR sky130_fd_sc_hd__decap_3
XFILLER_96_678 VGND VGND VPWR VPWR sky130_fd_sc_hd__decap_3
X_4061_ _7244_/Q _4433_/B _4436_/B1 _7180_/Q VGND VGND VPWR VPWR _4061_/X sky130_fd_sc_hd__a22o_2
XFILLER_110_477 VGND VGND VPWR VPWR sky130_fd_sc_hd__decap_3
XFILLER_49_594 VGND VGND VPWR VPWR sky130_fd_sc_hd__decap_3
XFILLER_83_328 VGND VGND VPWR VPWR sky130_fd_sc_hd__fill_1
XTAP_TAPCELL_ROW_39_718 VGND VPWR sky130_fd_sc_hd__tapvpwrvgnd_1
XFILLER_36_233 VGND VGND VPWR VPWR sky130_fd_sc_hd__decap_3
XFILLER_64_542 VGND VGND VPWR VPWR sky130_fd_sc_hd__decap_3
XFILLER_24_417 VGND VGND VPWR VPWR sky130_fd_sc_hd__decap_3
XFILLER_64_575 VGND VGND VPWR VPWR sky130_fd_sc_hd__decap_3
XFILLER_91_350 VGND VGND VPWR VPWR sky130_fd_sc_hd__decap_3
XFILLER_51_214 VGND VGND VPWR VPWR sky130_fd_sc_hd__decap_3
XFILLER_51_225 VGND VGND VPWR VPWR sky130_fd_sc_hd__decap_3
X_4963_ _4963_/A _4963_/B VGND VGND VPWR VPWR _6994_/D sky130_fd_sc_hd__nor2_2
XTAP_TAPCELL_ROW_19_475 VGND VPWR sky130_fd_sc_hd__tapvpwrvgnd_1
XFILLER_51_269 VGND VGND VPWR VPWR sky130_fd_sc_hd__decap_3
X_6702_ _6965_/CLK _6702_/D VGND VGND VPWR VPWR _6702_/Q sky130_fd_sc_hd__dfxtp_2
X_3914_ _3629_/A _3911_/X _3913_/X _3714_/X VGND VGND VPWR VPWR _3914_/X sky130_fd_sc_hd__a22o_2
XFILLER_20_601 VGND VGND VPWR VPWR sky130_fd_sc_hd__decap_3
XFILLER_20_634 VGND VGND VPWR VPWR sky130_fd_sc_hd__decap_3
X_6633_ _6633_/A VGND VGND VPWR VPWR _6633_/Y sky130_fd_sc_hd__inv_2
X_4894_ _4908_/A _4908_/B VGND VGND VPWR VPWR _4909_/B sky130_fd_sc_hd__and2_2
XFILLER_20_645 VGND VGND VPWR VPWR sky130_fd_sc_hd__decap_3
XFILLER_22_29 VGND VGND VPWR VPWR sky130_fd_sc_hd__fill_1
XFILLER_32_494 VGND VGND VPWR VPWR sky130_fd_sc_hd__fill_2
X_3845_ _3845_/A _3845_/B VGND VGND VPWR VPWR _3845_/X sky130_fd_sc_hd__or2_2
XFILLER_20_678 VGND VGND VPWR VPWR sky130_fd_sc_hd__decap_3
X_6564_ _6566_/A VGND VGND VPWR VPWR _6564_/Y sky130_fd_sc_hd__inv_2
X_3776_ _6727_/Q _3886_/A2 _3886_/B1 _6977_/Q VGND VGND VPWR VPWR _3776_/X sky130_fd_sc_hd__a22o_2
X_6495_ _6624_/A VGND VGND VPWR VPWR _6495_/Y sky130_fd_sc_hd__inv_2
XTAP_TAPCELL_ROW_115_1628 VGND VPWR sky130_fd_sc_hd__tapvpwrvgnd_1
XFILLER_87_612 VGND VGND VPWR VPWR sky130_fd_sc_hd__decap_3
Xoutput486 _3746_/C VGND VGND VPWR VPWR alu_result_out[5] sky130_fd_sc_hd__clkdlybuf4s25_1
Xoutput475 _5657_/A VGND VGND VPWR VPWR alu_result_out[24] sky130_fd_sc_hd__clkdlybuf4s25_1
Xoutput464 _5662_/A VGND VGND VPWR VPWR alu_result_out[14] sky130_fd_sc_hd__clkdlybuf4s25_1
X_5377_ _5377_/A0 _4822_/X _5383_/S VGND VGND VPWR VPWR _7144_/D sky130_fd_sc_hd__mux2_2
XFILLER_113_260 VGND VGND VPWR VPWR sky130_fd_sc_hd__decap_3
XFILLER_87_623 VGND VGND VPWR VPWR sky130_fd_sc_hd__decap_3
X_7116_ _7307_/CLK _7116_/D _6396_/Y VGND VGND VPWR VPWR _7116_/Q sky130_fd_sc_hd__dfrtp_2
Xoutput497 _3394_/A VGND VGND VPWR VPWR instruction_out[16] sky130_fd_sc_hd__clkdlybuf4s25_1
X_4328_ _4362_/A _4362_/B _4362_/C VGND VGND VPWR VPWR _5057_/B sky130_fd_sc_hd__a21boi_2
XFILLER_99_483 VGND VGND VPWR VPWR sky130_fd_sc_hd__decap_3
XFILLER_101_466 VGND VGND VPWR VPWR sky130_fd_sc_hd__decap_3
XFILLER_74_306 VGND VGND VPWR VPWR sky130_fd_sc_hd__fill_2
XFILLER_86_133 VGND VGND VPWR VPWR sky130_fd_sc_hd__decap_3
XFILLER_86_144 VGND VGND VPWR VPWR sky130_fd_sc_hd__decap_3
XFILLER_87_656 VGND VGND VPWR VPWR sky130_fd_sc_hd__decap_3
X_7047_ _7395_/CLK _7047_/D _6327_/Y VGND VGND VPWR VPWR _7047_/Q sky130_fd_sc_hd__dfrtp_2
XFILLER_101_477 VGND VGND VPWR VPWR sky130_fd_sc_hd__decap_3
XFILLER_74_339 VGND VGND VPWR VPWR sky130_fd_sc_hd__decap_3
XFILLER_86_177 VGND VGND VPWR VPWR sky130_fd_sc_hd__fill_2
XFILLER_103_21 VGND VGND VPWR VPWR sky130_fd_sc_hd__decap_3
XFILLER_27_244 VGND VGND VPWR VPWR sky130_fd_sc_hd__fill_2
XFILLER_103_54 VGND VGND VPWR VPWR sky130_fd_sc_hd__fill_2
XFILLER_27_277 VGND VGND VPWR VPWR sky130_fd_sc_hd__decap_3
XFILLER_55_564 VGND VGND VPWR VPWR sky130_fd_sc_hd__decap_3
XFILLER_15_439 VGND VGND VPWR VPWR sky130_fd_sc_hd__fill_1
XFILLER_27_299 VGND VGND VPWR VPWR sky130_fd_sc_hd__decap_3
XFILLER_55_597 VGND VGND VPWR VPWR sky130_fd_sc_hd__decap_3
XFILLER_70_567 VGND VGND VPWR VPWR sky130_fd_sc_hd__decap_3
XFILLER_11_612 VGND VGND VPWR VPWR sky130_fd_sc_hd__decap_3
XFILLER_11_623 VGND VGND VPWR VPWR sky130_fd_sc_hd__decap_3
XFILLER_70_589 VGND VGND VPWR VPWR sky130_fd_sc_hd__decap_3
XFILLER_11_656 VGND VGND VPWR VPWR sky130_fd_sc_hd__decap_3
XFILLER_23_494 VGND VGND VPWR VPWR sky130_fd_sc_hd__fill_1
XFILLER_50_280 VGND VGND VPWR VPWR sky130_fd_sc_hd__decap_3
XFILLER_109_500 VGND VGND VPWR VPWR sky130_fd_sc_hd__decap_3
XFILLER_109_511 VGND VGND VPWR VPWR sky130_fd_sc_hd__decap_3
XFILLER_10_144 VGND VGND VPWR VPWR sky130_fd_sc_hd__fill_2
XFILLER_7_638 VGND VGND VPWR VPWR sky130_fd_sc_hd__decap_3
XFILLER_109_544 VGND VGND VPWR VPWR sky130_fd_sc_hd__decap_3
XFILLER_12_40 VGND VGND VPWR VPWR sky130_fd_sc_hd__decap_3
Xwire569 wire569/A VGND VGND VPWR VPWR _6278_/A sky130_fd_sc_hd__buf_2
XFILLER_109_588 VGND VGND VPWR VPWR sky130_fd_sc_hd__decap_3
XFILLER_2_365 VGND VGND VPWR VPWR sky130_fd_sc_hd__fill_2
XFILLER_78_601 VGND VGND VPWR VPWR sky130_fd_sc_hd__decap_3
XFILLER_88_88 VGND VGND VPWR VPWR sky130_fd_sc_hd__decap_3
XFILLER_2_376 VGND VGND VPWR VPWR sky130_fd_sc_hd__decap_3
XFILLER_77_100 VGND VGND VPWR VPWR sky130_fd_sc_hd__fill_1
XFILLER_78_634 VGND VGND VPWR VPWR sky130_fd_sc_hd__decap_3
XFILLER_78_645 VGND VGND VPWR VPWR sky130_fd_sc_hd__decap_3
XFILLER_78_678 VGND VGND VPWR VPWR sky130_fd_sc_hd__decap_3
XFILLER_19_9 VGND VGND VPWR VPWR sky130_fd_sc_hd__fill_1
XFILLER_65_306 VGND VGND VPWR VPWR sky130_fd_sc_hd__decap_3
XFILLER_93_615 VGND VGND VPWR VPWR sky130_fd_sc_hd__fill_1
XFILLER_93_626 VGND VGND VPWR VPWR sky130_fd_sc_hd__decap_3
XFILLER_46_531 VGND VGND VPWR VPWR sky130_fd_sc_hd__fill_1
XFILLER_92_136 VGND VGND VPWR VPWR sky130_fd_sc_hd__decap_3
XFILLER_93_659 VGND VGND VPWR VPWR sky130_fd_sc_hd__decap_3
XFILLER_18_244 VGND VGND VPWR VPWR sky130_fd_sc_hd__fill_1
XFILLER_46_564 VGND VGND VPWR VPWR sky130_fd_sc_hd__decap_3
XFILLER_73_361 VGND VGND VPWR VPWR sky130_fd_sc_hd__decap_3
XFILLER_80_309 VGND VGND VPWR VPWR sky130_fd_sc_hd__fill_1
XFILLER_33_225 VGND VGND VPWR VPWR sky130_fd_sc_hd__decap_3
XFILLER_33_258 VGND VGND VPWR VPWR sky130_fd_sc_hd__decap_3
XFILLER_61_567 VGND VGND VPWR VPWR sky130_fd_sc_hd__decap_3
XTAP_TAPCELL_ROW_16_445 VGND VPWR sky130_fd_sc_hd__tapvpwrvgnd_1
XFILLER_14_483 VGND VGND VPWR VPWR sky130_fd_sc_hd__fill_1
XTAP_TAPCELL_ROW_44_776 VGND VPWR sky130_fd_sc_hd__tapvpwrvgnd_1
X_3630_ _3630_/A _3630_/B VGND VGND VPWR VPWR _3636_/B sky130_fd_sc_hd__and2_2
X_3561_ _3561_/A _3561_/B _5668_/A VGND VGND VPWR VPWR _3561_/X sky130_fd_sc_hd__or3_2
XFILLER_115_503 VGND VGND VPWR VPWR sky130_fd_sc_hd__fill_1
XFILLER_115_514 VGND VGND VPWR VPWR sky130_fd_sc_hd__decap_3
XFILLER_6_660 VGND VGND VPWR VPWR sky130_fd_sc_hd__decap_3
X_5300_ _5300_/A0 _4752_/X _5315_/S VGND VGND VPWR VPWR _7180_/D sky130_fd_sc_hd__mux2_2
XFILLER_115_547 VGND VGND VPWR VPWR sky130_fd_sc_hd__decap_3
XFILLER_5_181 VGND VGND VPWR VPWR sky130_fd_sc_hd__decap_3
X_6280_ _6462_/A VGND VGND VPWR VPWR _6280_/Y sky130_fd_sc_hd__inv_2
X_3492_ _7055_/Q _3577_/B _3487_/X _3491_/X VGND VGND VPWR VPWR _4460_/B sky130_fd_sc_hd__o22a_2
XFILLER_69_612 VGND VGND VPWR VPWR sky130_fd_sc_hd__decap_3
XFILLER_69_623 VGND VGND VPWR VPWR sky130_fd_sc_hd__decap_3
XFILLER_69_656 VGND VGND VPWR VPWR sky130_fd_sc_hd__decap_3
XFILLER_84_604 VGND VGND VPWR VPWR sky130_fd_sc_hd__decap_3
XFILLER_96_453 VGND VGND VPWR VPWR sky130_fd_sc_hd__fill_1
XFILLER_96_464 VGND VGND VPWR VPWR sky130_fd_sc_hd__decap_3
X_5093_ _5117_/A _3867_/X _5658_/C _5092_/X _3346_/A VGND VGND VPWR VPWR _5093_/X
+ sky130_fd_sc_hd__o32a_2
X_4113_ _7364_/Q _4261_/A2 _4112_/X _4347_/C1 VGND VGND VPWR VPWR _4113_/X sky130_fd_sc_hd__a211o_2
XTAP_TAPCELL_ROW_110_1569 VGND VPWR sky130_fd_sc_hd__tapvpwrvgnd_1
XFILLER_56_306 VGND VGND VPWR VPWR sky130_fd_sc_hd__fill_2
XFILLER_68_177 VGND VGND VPWR VPWR sky130_fd_sc_hd__decap_3
XFILLER_84_637 VGND VGND VPWR VPWR sky130_fd_sc_hd__decap_3
XFILLER_96_497 VGND VGND VPWR VPWR sky130_fd_sc_hd__decap_3
XFILLER_49_391 VGND VGND VPWR VPWR sky130_fd_sc_hd__fill_1
XFILLER_84_648 VGND VGND VPWR VPWR sky130_fd_sc_hd__decap_3
X_4044_ _7277_/Q _4437_/A2 _4041_/X _4043_/X VGND VGND VPWR VPWR _4044_/X sky130_fd_sc_hd__a211o_2
XFILLER_37_553 VGND VGND VPWR VPWR sky130_fd_sc_hd__decap_3
XFILLER_37_564 VGND VGND VPWR VPWR sky130_fd_sc_hd__decap_3
XFILLER_83_169 VGND VGND VPWR VPWR sky130_fd_sc_hd__fill_1
XFILLER_24_203 VGND VGND VPWR VPWR sky130_fd_sc_hd__fill_1
XFILLER_24_225 VGND VGND VPWR VPWR sky130_fd_sc_hd__decap_3
XFILLER_37_597 VGND VGND VPWR VPWR sky130_fd_sc_hd__decap_3
XFILLER_92_681 VGND VGND VPWR VPWR sky130_fd_sc_hd__decap_3
XTAP_TAPCELL_ROW_65_1037 VGND VPWR sky130_fd_sc_hd__tapvpwrvgnd_1
XTAP_TAPCELL_ROW_65_1026 VGND VPWR sky130_fd_sc_hd__tapvpwrvgnd_1
XFILLER_91_191 VGND VGND VPWR VPWR sky130_fd_sc_hd__decap_3
XFILLER_33_39 VGND VGND VPWR VPWR sky130_fd_sc_hd__fill_2
XFILLER_52_589 VGND VGND VPWR VPWR sky130_fd_sc_hd__decap_3
X_4946_ _4946_/A0 _4945_/X _4946_/S VGND VGND VPWR VPWR _7265_/D sky130_fd_sc_hd__mux2_2
XFILLER_20_431 VGND VGND VPWR VPWR sky130_fd_sc_hd__decap_3
X_4877_ _4799_/A _5663_/C _3753_/X _3346_/A VGND VGND VPWR VPWR _4877_/X sky130_fd_sc_hd__o211a_2
X_6616_ _6616_/A VGND VGND VPWR VPWR _6616_/Y sky130_fd_sc_hd__inv_2
X_3828_ _6926_/Q _3918_/A2 _3903_/A2 _6790_/Q _3827_/X VGND VGND VPWR VPWR _3828_/X
+ sky130_fd_sc_hd__a221o_2
X_6547_ _6652_/A VGND VGND VPWR VPWR _6547_/Y sky130_fd_sc_hd__inv_2
XFILLER_106_525 VGND VGND VPWR VPWR sky130_fd_sc_hd__decap_3
XFILLER_4_619 VGND VGND VPWR VPWR sky130_fd_sc_hd__decap_3
X_3759_ _6797_/Q _3918_/B1 _3902_/B1 _6885_/Q VGND VGND VPWR VPWR _3759_/X sky130_fd_sc_hd__a22o_2
XFILLER_106_536 VGND VGND VPWR VPWR sky130_fd_sc_hd__decap_3
X_6478_ _6637_/A VGND VGND VPWR VPWR _6478_/Y sky130_fd_sc_hd__inv_2
XTAP_TAPCELL_ROW_76_1166 VGND VPWR sky130_fd_sc_hd__tapvpwrvgnd_1
XFILLER_106_569 VGND VGND VPWR VPWR sky130_fd_sc_hd__decap_3
X_5429_ _5429_/A0 _4470_/X _5429_/S VGND VGND VPWR VPWR _7119_/D sky130_fd_sc_hd__mux2_2
XFILLER_87_420 VGND VGND VPWR VPWR sky130_fd_sc_hd__fill_2
XFILLER_99_291 VGND VGND VPWR VPWR sky130_fd_sc_hd__decap_3
XFILLER_47_317 VGND VGND VPWR VPWR sky130_fd_sc_hd__decap_3
XFILLER_74_103 VGND VGND VPWR VPWR sky130_fd_sc_hd__decap_3
XFILLER_75_615 VGND VGND VPWR VPWR sky130_fd_sc_hd__fill_1
XFILLER_75_626 VGND VGND VPWR VPWR sky130_fd_sc_hd__decap_3
XFILLER_114_53 VGND VGND VPWR VPWR sky130_fd_sc_hd__decap_3
XFILLER_28_542 VGND VGND VPWR VPWR sky130_fd_sc_hd__decap_3
XFILLER_74_136 VGND VGND VPWR VPWR sky130_fd_sc_hd__decap_3
XFILLER_75_659 VGND VGND VPWR VPWR sky130_fd_sc_hd__decap_3
XFILLER_114_97 VGND VGND VPWR VPWR sky130_fd_sc_hd__decap_3
XFILLER_28_575 VGND VGND VPWR VPWR sky130_fd_sc_hd__decap_3
XFILLER_43_501 VGND VGND VPWR VPWR sky130_fd_sc_hd__decap_3
XFILLER_62_309 VGND VGND VPWR VPWR sky130_fd_sc_hd__fill_2
XFILLER_90_607 VGND VGND VPWR VPWR sky130_fd_sc_hd__decap_3
XFILLER_15_203 VGND VGND VPWR VPWR sky130_fd_sc_hd__decap_3
XFILLER_15_225 VGND VGND VPWR VPWR sky130_fd_sc_hd__decap_3
XTAP_TAPCELL_ROW_87_1295 VGND VPWR sky130_fd_sc_hd__tapvpwrvgnd_1
XFILLER_43_567 VGND VGND VPWR VPWR sky130_fd_sc_hd__decap_3
XFILLER_70_342 VGND VGND VPWR VPWR sky130_fd_sc_hd__fill_1
XFILLER_90_12 VGND VGND VPWR VPWR sky130_fd_sc_hd__decap_3
XTAP_TAPCELL_ROW_13_404 VGND VPWR sky130_fd_sc_hd__tapvpwrvgnd_1
XFILLER_90_56 VGND VGND VPWR VPWR sky130_fd_sc_hd__decap_3
XTAP_TAPCELL_ROW_41_746 VGND VPWR sky130_fd_sc_hd__tapvpwrvgnd_1
XFILLER_109_330 VGND VGND VPWR VPWR sky130_fd_sc_hd__fill_1
XFILLER_23_94 VGND VGND VPWR VPWR sky130_fd_sc_hd__fill_1
XFILLER_109_374 VGND VGND VPWR VPWR sky130_fd_sc_hd__decap_3
XFILLER_7_468 VGND VGND VPWR VPWR sky130_fd_sc_hd__fill_2
XFILLER_109_396 VGND VGND VPWR VPWR sky130_fd_sc_hd__decap_3
XFILLER_3_641 VGND VGND VPWR VPWR sky130_fd_sc_hd__decap_3
XFILLER_112_528 VGND VGND VPWR VPWR sky130_fd_sc_hd__decap_3
XFILLER_112_539 VGND VGND VPWR VPWR sky130_fd_sc_hd__decap_3
XFILLER_2_173 VGND VGND VPWR VPWR sky130_fd_sc_hd__decap_3
XFILLER_3_685 VGND VGND VPWR VPWR sky130_fd_sc_hd__decap_3
XFILLER_105_591 VGND VGND VPWR VPWR sky130_fd_sc_hd__decap_3
XFILLER_2_184 VGND VGND VPWR VPWR sky130_fd_sc_hd__decap_3
XFILLER_66_604 VGND VGND VPWR VPWR sky130_fd_sc_hd__decap_3
XFILLER_66_637 VGND VGND VPWR VPWR sky130_fd_sc_hd__decap_3
XFILLER_0_10 VGND VGND VPWR VPWR sky130_fd_sc_hd__decap_3
XFILLER_19_531 VGND VGND VPWR VPWR sky130_fd_sc_hd__decap_3
XFILLER_48_80 VGND VGND VPWR VPWR sky130_fd_sc_hd__decap_3
XFILLER_66_648 VGND VGND VPWR VPWR sky130_fd_sc_hd__decap_3
XFILLER_93_434 VGND VGND VPWR VPWR sky130_fd_sc_hd__decap_3
XTAP_TAPCELL_ROW_49_835 VGND VPWR sky130_fd_sc_hd__tapvpwrvgnd_1
XFILLER_19_564 VGND VGND VPWR VPWR sky130_fd_sc_hd__decap_3
XFILLER_65_169 VGND VGND VPWR VPWR sky130_fd_sc_hd__decap_3
XFILLER_81_629 VGND VGND VPWR VPWR sky130_fd_sc_hd__decap_3
XFILLER_93_489 VGND VGND VPWR VPWR sky130_fd_sc_hd__fill_2
XFILLER_19_597 VGND VGND VPWR VPWR sky130_fd_sc_hd__decap_3
XFILLER_61_320 VGND VGND VPWR VPWR sky130_fd_sc_hd__decap_3
XFILLER_74_681 VGND VGND VPWR VPWR sky130_fd_sc_hd__decap_3
XFILLER_80_139 VGND VGND VPWR VPWR sky130_fd_sc_hd__fill_1
XFILLER_34_556 VGND VGND VPWR VPWR sky130_fd_sc_hd__decap_3
XFILLER_61_353 VGND VGND VPWR VPWR sky130_fd_sc_hd__fill_1
X_4800_ _7002_/Q _4826_/A _7003_/Q VGND VGND VPWR VPWR _4801_/B sky130_fd_sc_hd__a21oi_2
XFILLER_21_228 VGND VGND VPWR VPWR sky130_fd_sc_hd__decap_3
XFILLER_34_589 VGND VGND VPWR VPWR sky130_fd_sc_hd__decap_3
X_4731_ _4731_/A _4731_/B VGND VGND VPWR VPWR _7007_/D sky130_fd_sc_hd__and2_2
X_4662_ _4969_/B _4457_/X _4660_/X _4811_/C _4040_/Y VGND VGND VPWR VPWR _4662_/Y
+ sky130_fd_sc_hd__a221oi_2
X_6401_ _6603_/A VGND VGND VPWR VPWR _6401_/Y sky130_fd_sc_hd__inv_2
X_3613_ _3603_/Y _3606_/X _3612_/X VGND VGND VPWR VPWR _3614_/B sky130_fd_sc_hd__a21oi_2
X_7381_ _7383_/CLK _7381_/D _6661_/Y VGND VGND VPWR VPWR _7381_/Q sky130_fd_sc_hd__dfrtp_2
Xhold903 _7113_/Q VGND VGND VPWR VPWR _7113_/D sky130_fd_sc_hd__dlygate4sd3_1
X_4593_ _4593_/A _4595_/B VGND VGND VPWR VPWR _7284_/D sky130_fd_sc_hd__and2_2
XFILLER_115_311 VGND VGND VPWR VPWR sky130_fd_sc_hd__decap_3
Xhold914 _6701_/Q VGND VGND VPWR VPWR hold914/X sky130_fd_sc_hd__dlygate4sd3_1
Xhold925 _7031_/Q VGND VGND VPWR VPWR _5593_/A sky130_fd_sc_hd__dlygate4sd3_1
Xhold936 _6700_/Q VGND VGND VPWR VPWR hold936/X sky130_fd_sc_hd__dlygate4sd3_1
X_6332_ _6649_/A VGND VGND VPWR VPWR _6332_/Y sky130_fd_sc_hd__inv_2
X_3544_ _3544_/A _3544_/B VGND VGND VPWR VPWR _3635_/A sky130_fd_sc_hd__nor2_2
XFILLER_103_517 VGND VGND VPWR VPWR sky130_fd_sc_hd__decap_3
Xhold969 _7389_/Q VGND VGND VPWR VPWR hold969/X sky130_fd_sc_hd__dlygate4sd3_1
Xhold958 _7035_/Q VGND VGND VPWR VPWR hold958/X sky130_fd_sc_hd__dlygate4sd3_1
Xhold947 _7043_/Q VGND VGND VPWR VPWR hold947/X sky130_fd_sc_hd__dlygate4sd3_1
X_6263_ _6629_/A VGND VGND VPWR VPWR _6263_/Y sky130_fd_sc_hd__inv_2
X_3475_ _7248_/Q _4601_/S _3472_/X _3474_/X VGND VGND VPWR VPWR _3502_/A sky130_fd_sc_hd__a211oi_2
XFILLER_115_399 VGND VGND VPWR VPWR sky130_fd_sc_hd__decap_3
XFILLER_88_217 VGND VGND VPWR VPWR sky130_fd_sc_hd__decap_3
XFILLER_111_550 VGND VGND VPWR VPWR sky130_fd_sc_hd__decap_3
XFILLER_111_561 VGND VGND VPWR VPWR sky130_fd_sc_hd__decap_3
XFILLER_29_328 VGND VGND VPWR VPWR sky130_fd_sc_hd__decap_3
XFILLER_57_615 VGND VGND VPWR VPWR sky130_fd_sc_hd__fill_1
XFILLER_57_626 VGND VGND VPWR VPWR sky130_fd_sc_hd__decap_3
X_5145_ _5145_/A _3500_/Y VGND VGND VPWR VPWR _5145_/X sky130_fd_sc_hd__or2b_2
XFILLER_111_594 VGND VGND VPWR VPWR sky130_fd_sc_hd__decap_3
XFILLER_57_659 VGND VGND VPWR VPWR sky130_fd_sc_hd__decap_3
XFILLER_84_434 VGND VGND VPWR VPWR sky130_fd_sc_hd__fill_1
XFILLER_84_456 VGND VGND VPWR VPWR sky130_fd_sc_hd__fill_2
XFILLER_96_294 VGND VGND VPWR VPWR sky130_fd_sc_hd__decap_3
XFILLER_44_309 VGND VGND VPWR VPWR sky130_fd_sc_hd__decap_3
XFILLER_72_607 VGND VGND VPWR VPWR sky130_fd_sc_hd__decap_3
XFILLER_84_467 VGND VGND VPWR VPWR sky130_fd_sc_hd__decap_3
XFILLER_71_128 VGND VGND VPWR VPWR sky130_fd_sc_hd__decap_3
XFILLER_25_567 VGND VGND VPWR VPWR sky130_fd_sc_hd__decap_3
XFILLER_44_27 VGND VGND VPWR VPWR sky130_fd_sc_hd__fill_1
XFILLER_52_342 VGND VGND VPWR VPWR sky130_fd_sc_hd__fill_1
XFILLER_80_640 VGND VGND VPWR VPWR sky130_fd_sc_hd__decap_3
XFILLER_80_651 VGND VGND VPWR VPWR sky130_fd_sc_hd__decap_3
XFILLER_80_684 VGND VGND VPWR VPWR sky130_fd_sc_hd__decap_3
XFILLER_100_33 VGND VGND VPWR VPWR sky130_fd_sc_hd__fill_2
XFILLER_12_228 VGND VGND VPWR VPWR sky130_fd_sc_hd__fill_2
X_4929_ _4908_/B _4928_/Y _4983_/A VGND VGND VPWR VPWR _4929_/Y sky130_fd_sc_hd__o21ai_2
XFILLER_100_88 VGND VGND VPWR VPWR sky130_fd_sc_hd__decap_3
XFILLER_106_300 VGND VGND VPWR VPWR sky130_fd_sc_hd__fill_1
XFILLER_109_20 VGND VGND VPWR VPWR sky130_fd_sc_hd__decap_3
XFILLER_109_53 VGND VGND VPWR VPWR sky130_fd_sc_hd__decap_3
XFILLER_4_438 VGND VGND VPWR VPWR sky130_fd_sc_hd__fill_1
XFILLER_69_57 VGND VGND VPWR VPWR sky130_fd_sc_hd__decap_3
XFILLER_79_228 VGND VGND VPWR VPWR sky130_fd_sc_hd__decap_3
XFILLER_102_572 VGND VGND VPWR VPWR sky130_fd_sc_hd__decap_3
XFILLER_48_604 VGND VGND VPWR VPWR sky130_fd_sc_hd__decap_3
XFILLER_75_401 VGND VGND VPWR VPWR sky130_fd_sc_hd__decap_3
XFILLER_87_272 VGND VGND VPWR VPWR sky130_fd_sc_hd__fill_2
XFILLER_48_637 VGND VGND VPWR VPWR sky130_fd_sc_hd__decap_3
XFILLER_48_648 VGND VGND VPWR VPWR sky130_fd_sc_hd__decap_3
XFILLER_75_445 VGND VGND VPWR VPWR sky130_fd_sc_hd__decap_3
XTAP_TAPCELL_ROW_89_1324 VGND VPWR sky130_fd_sc_hd__tapvpwrvgnd_1
XFILLER_18_50 VGND VGND VPWR VPWR sky130_fd_sc_hd__fill_1
XFILLER_47_169 VGND VGND VPWR VPWR sky130_fd_sc_hd__decap_3
XFILLER_63_629 VGND VGND VPWR VPWR sky130_fd_sc_hd__decap_3
XFILLER_90_404 VGND VGND VPWR VPWR sky130_fd_sc_hd__decap_3
XTAP_TAPCELL_ROW_46_805 VGND VPWR sky130_fd_sc_hd__tapvpwrvgnd_1
XFILLER_16_523 VGND VGND VPWR VPWR sky130_fd_sc_hd__decap_3
XFILLER_28_361 VGND VGND VPWR VPWR sky130_fd_sc_hd__decap_3
XFILLER_56_681 VGND VGND VPWR VPWR sky130_fd_sc_hd__decap_3
XFILLER_90_437 VGND VGND VPWR VPWR sky130_fd_sc_hd__decap_3
XFILLER_16_545 VGND VGND VPWR VPWR sky130_fd_sc_hd__decap_3
XFILLER_43_320 VGND VGND VPWR VPWR sky130_fd_sc_hd__decap_3
XFILLER_71_662 VGND VGND VPWR VPWR sky130_fd_sc_hd__decap_3
XFILLER_16_578 VGND VGND VPWR VPWR sky130_fd_sc_hd__decap_3
XFILLER_16_589 VGND VGND VPWR VPWR sky130_fd_sc_hd__decap_3
XFILLER_43_386 VGND VGND VPWR VPWR sky130_fd_sc_hd__decap_3
XFILLER_71_673 VGND VGND VPWR VPWR sky130_fd_sc_hd__decap_3
XTAP_TAPCELL_ROW_26_562 VGND VPWR sky130_fd_sc_hd__tapvpwrvgnd_1
XFILLER_31_559 VGND VGND VPWR VPWR sky130_fd_sc_hd__fill_1
XFILLER_11_294 VGND VGND VPWR VPWR sky130_fd_sc_hd__fill_2
XFILLER_98_504 VGND VGND VPWR VPWR sky130_fd_sc_hd__decap_3
XFILLER_112_303 VGND VGND VPWR VPWR sky130_fd_sc_hd__decap_3
XFILLER_98_548 VGND VGND VPWR VPWR sky130_fd_sc_hd__decap_3
XFILLER_3_493 VGND VGND VPWR VPWR sky130_fd_sc_hd__decap_3
XFILLER_39_615 VGND VGND VPWR VPWR sky130_fd_sc_hd__fill_1
XFILLER_39_626 VGND VGND VPWR VPWR sky130_fd_sc_hd__decap_3
XFILLER_15_3 VGND VGND VPWR VPWR sky130_fd_sc_hd__decap_3
XFILLER_38_125 VGND VGND VPWR VPWR sky130_fd_sc_hd__decap_3
XFILLER_39_659 VGND VGND VPWR VPWR sky130_fd_sc_hd__decap_3
XFILLER_78_294 VGND VGND VPWR VPWR sky130_fd_sc_hd__decap_3
XFILLER_26_309 VGND VGND VPWR VPWR sky130_fd_sc_hd__decap_3
XFILLER_54_607 VGND VGND VPWR VPWR sky130_fd_sc_hd__decap_3
X_6950_ _6968_/CLK _6950_/D VGND VGND VPWR VPWR _6950_/Q sky130_fd_sc_hd__dfxtp_2
XFILLER_81_437 VGND VGND VPWR VPWR sky130_fd_sc_hd__decap_3
XTAP_TAPCELL_ROW_109_1560 VGND VPWR sky130_fd_sc_hd__tapvpwrvgnd_1
XFILLER_34_342 VGND VGND VPWR VPWR sky130_fd_sc_hd__decap_3
XFILLER_62_640 VGND VGND VPWR VPWR sky130_fd_sc_hd__decap_3
XFILLER_62_651 VGND VGND VPWR VPWR sky130_fd_sc_hd__decap_3
X_6881_ _7378_/CLK _6881_/D VGND VGND VPWR VPWR _6881_/Q sky130_fd_sc_hd__dfxtp_2
XFILLER_22_526 VGND VGND VPWR VPWR sky130_fd_sc_hd__fill_2
XFILLER_62_684 VGND VGND VPWR VPWR sky130_fd_sc_hd__decap_3
XFILLER_22_559 VGND VGND VPWR VPWR sky130_fd_sc_hd__decap_3
XFILLER_61_194 VGND VGND VPWR VPWR sky130_fd_sc_hd__fill_1
XPHY_EDGE_ROW_101_Left_218 VGND VGND VPWR VPWR sky130_fd_sc_hd__decap_3
XFILLER_30_570 VGND VGND VPWR VPWR sky130_fd_sc_hd__decap_3
XFILLER_30_592 VGND VGND VPWR VPWR sky130_fd_sc_hd__decap_3
XFILLER_30_29 VGND VGND VPWR VPWR sky130_fd_sc_hd__fill_2
X_4645_ _4633_/X _4903_/B _4644_/X _4096_/A VGND VGND VPWR VPWR _4646_/B sky130_fd_sc_hd__o211a_2
XFILLER_116_620 VGND VGND VPWR VPWR sky130_fd_sc_hd__decap_3
XFILLER_116_631 VGND VGND VPWR VPWR sky130_fd_sc_hd__decap_3
X_7364_ _7364_/CLK _7364_/D _6644_/Y VGND VGND VPWR VPWR _7364_/Q sky130_fd_sc_hd__dfrtp_2
Xhold700 _6867_/Q VGND VGND VPWR VPWR _6867_/D sky130_fd_sc_hd__dlygate4sd3_1
Xhold711 _6933_/Q VGND VGND VPWR VPWR _6933_/D sky130_fd_sc_hd__dlygate4sd3_1
XFILLER_116_653 VGND VGND VPWR VPWR sky130_fd_sc_hd__decap_3
Xhold722 _6815_/Q VGND VGND VPWR VPWR _6815_/D sky130_fd_sc_hd__dlygate4sd3_1
Xhold733 _6799_/Q VGND VGND VPWR VPWR _6799_/D sky130_fd_sc_hd__dlygate4sd3_1
Xhold744 _6884_/Q VGND VGND VPWR VPWR _6884_/D sky130_fd_sc_hd__dlygate4sd3_1
Xhold755 _6828_/Q VGND VGND VPWR VPWR _6828_/D sky130_fd_sc_hd__dlygate4sd3_1
X_6315_ _6629_/A VGND VGND VPWR VPWR _6315_/Y sky130_fd_sc_hd__inv_2
X_3527_ _3527_/A _3427_/B VGND VGND VPWR VPWR _4614_/A sky130_fd_sc_hd__nor2b_2
XFILLER_115_152 VGND VGND VPWR VPWR sky130_fd_sc_hd__decap_3
XFILLER_89_526 VGND VGND VPWR VPWR sky130_fd_sc_hd__decap_3
X_7295_ _7328_/CLK _7295_/D _6575_/Y VGND VGND VPWR VPWR _7295_/Q sky130_fd_sc_hd__dfrtp_2
Xhold766 _6783_/Q VGND VGND VPWR VPWR _6783_/D sky130_fd_sc_hd__dlygate4sd3_1
Xhold777 _6785_/Q VGND VGND VPWR VPWR _6785_/D sky130_fd_sc_hd__dlygate4sd3_1
Xhold788 _6775_/Q VGND VGND VPWR VPWR _6775_/D sky130_fd_sc_hd__dlygate4sd3_1
XTAP_TAPCELL_ROW_73_1125 VGND VPWR sky130_fd_sc_hd__tapvpwrvgnd_1
XFILLER_89_559 VGND VGND VPWR VPWR sky130_fd_sc_hd__fill_1
Xhold799 _6960_/Q VGND VGND VPWR VPWR _6960_/D sky130_fd_sc_hd__dlygate4sd3_1
X_3458_ _3544_/A _3506_/B VGND VGND VPWR VPWR _3458_/Y sky130_fd_sc_hd__nor2_2
XPHY_EDGE_ROW_110_Left_227 VGND VGND VPWR VPWR sky130_fd_sc_hd__decap_3
XFILLER_103_369 VGND VGND VPWR VPWR sky130_fd_sc_hd__decap_3
XFILLER_57_412 VGND VGND VPWR VPWR sky130_fd_sc_hd__decap_3
XFILLER_97_570 VGND VGND VPWR VPWR sky130_fd_sc_hd__decap_3
X_3389_ _7347_/Q _4278_/B1 _3384_/X _3556_/A VGND VGND VPWR VPWR _3389_/X sky130_fd_sc_hd__a211o_2
XFILLER_29_125 VGND VGND VPWR VPWR sky130_fd_sc_hd__fill_2
XFILLER_69_272 VGND VGND VPWR VPWR sky130_fd_sc_hd__decap_3
XFILLER_69_294 VGND VGND VPWR VPWR sky130_fd_sc_hd__decap_3
X_5128_ _3733_/C _3904_/Y _4677_/B VGND VGND VPWR VPWR _5128_/Y sky130_fd_sc_hd__a21oi_2
XFILLER_29_169 VGND VGND VPWR VPWR sky130_fd_sc_hd__decap_3
XFILLER_55_15 VGND VGND VPWR VPWR sky130_fd_sc_hd__decap_3
XFILLER_84_253 VGND VGND VPWR VPWR sky130_fd_sc_hd__decap_3
XFILLER_38_681 VGND VGND VPWR VPWR sky130_fd_sc_hd__decap_3
XFILLER_45_629 VGND VGND VPWR VPWR sky130_fd_sc_hd__decap_3
X_5059_ _3833_/S _3859_/X _5662_/B VGND VGND VPWR VPWR _5059_/X sky130_fd_sc_hd__a21o_2
XFILLER_111_21 VGND VGND VPWR VPWR sky130_fd_sc_hd__decap_3
XFILLER_44_139 VGND VGND VPWR VPWR sky130_fd_sc_hd__fill_1
XFILLER_111_54 VGND VGND VPWR VPWR sky130_fd_sc_hd__fill_2
XFILLER_53_662 VGND VGND VPWR VPWR sky130_fd_sc_hd__decap_3
XFILLER_53_673 VGND VGND VPWR VPWR sky130_fd_sc_hd__decap_3
XTAP_TAPCELL_ROW_84_1265 VGND VPWR sky130_fd_sc_hd__tapvpwrvgnd_1
XTAP_TAPCELL_ROW_84_1254 VGND VPWR sky130_fd_sc_hd__tapvpwrvgnd_1
XFILLER_13_537 VGND VGND VPWR VPWR sky130_fd_sc_hd__decap_3
XFILLER_40_312 VGND VGND VPWR VPWR sky130_fd_sc_hd__decap_3
XFILLER_71_14 VGND VGND VPWR VPWR sky130_fd_sc_hd__fill_1
XTAP_TAPCELL_ROW_23_532 VGND VPWR sky130_fd_sc_hd__tapvpwrvgnd_1
XFILLER_9_508 VGND VGND VPWR VPWR sky130_fd_sc_hd__decap_3
XFILLER_40_356 VGND VGND VPWR VPWR sky130_fd_sc_hd__fill_1
XTAP_TAPCELL_ROW_51_863 VGND VPWR sky130_fd_sc_hd__tapvpwrvgnd_1
XFILLER_21_570 VGND VGND VPWR VPWR sky130_fd_sc_hd__decap_3
XPHY_EDGE_ROW_109_Right_109 VGND VGND VPWR VPWR sky130_fd_sc_hd__decap_3
XFILLER_107_620 VGND VGND VPWR VPWR sky130_fd_sc_hd__decap_3
XFILLER_106_141 VGND VGND VPWR VPWR sky130_fd_sc_hd__decap_3
XFILLER_107_653 VGND VGND VPWR VPWR sky130_fd_sc_hd__decap_3
XFILLER_4_235 VGND VGND VPWR VPWR sky130_fd_sc_hd__decap_3
XFILLER_106_174 VGND VGND VPWR VPWR sky130_fd_sc_hd__decap_3
XFILLER_20_62 VGND VGND VPWR VPWR sky130_fd_sc_hd__fill_2
XTAP_TAPCELL_ROW_95_1394 VGND VPWR sky130_fd_sc_hd__tapvpwrvgnd_1
XFILLER_0_463 VGND VGND VPWR VPWR sky130_fd_sc_hd__decap_3
XFILLER_95_529 VGND VGND VPWR VPWR sky130_fd_sc_hd__decap_3
XFILLER_29_60 VGND VGND VPWR VPWR sky130_fd_sc_hd__fill_2
XFILLER_48_412 VGND VGND VPWR VPWR sky130_fd_sc_hd__decap_3
XFILLER_88_581 VGND VGND VPWR VPWR sky130_fd_sc_hd__decap_3
XFILLER_88_592 VGND VGND VPWR VPWR sky130_fd_sc_hd__decap_3
XFILLER_96_99 VGND VGND VPWR VPWR sky130_fd_sc_hd__decap_3
XFILLER_29_82 VGND VGND VPWR VPWR sky130_fd_sc_hd__fill_1
XFILLER_36_607 VGND VGND VPWR VPWR sky130_fd_sc_hd__decap_3
XFILLER_75_231 VGND VGND VPWR VPWR sky130_fd_sc_hd__decap_3
XFILLER_75_264 VGND VGND VPWR VPWR sky130_fd_sc_hd__fill_1
XTAP_TAPCELL_ROW_59_963 VGND VPWR sky130_fd_sc_hd__tapvpwrvgnd_1
XFILLER_63_437 VGND VGND VPWR VPWR sky130_fd_sc_hd__fill_2
XFILLER_75_275 VGND VGND VPWR VPWR sky130_fd_sc_hd__decap_3
Xplace404 _4534_/S VGND VGND VPWR VPWR _4517_/S sky130_fd_sc_hd__buf_2
XFILLER_28_180 VGND VGND VPWR VPWR sky130_fd_sc_hd__decap_3
XFILLER_44_640 VGND VGND VPWR VPWR sky130_fd_sc_hd__decap_3
XFILLER_44_651 VGND VGND VPWR VPWR sky130_fd_sc_hd__decap_3
Xplace415 _4285_/B1 VGND VGND VPWR VPWR _4338_/B1 sky130_fd_sc_hd__buf_2
Xplace426 _3987_/S VGND VGND VPWR VPWR _3996_/S sky130_fd_sc_hd__buf_2
Xplace437 _5117_/A VGND VGND VPWR VPWR _5593_/B sky130_fd_sc_hd__buf_2
XTAP_TAPCELL_ROW_3_290 VGND VPWR sky130_fd_sc_hd__tapvpwrvgnd_1
XFILLER_44_684 VGND VGND VPWR VPWR sky130_fd_sc_hd__decap_3
Xplace448 _3561_/B VGND VGND VPWR VPWR _5670_/A sky130_fd_sc_hd__buf_2
XFILLER_43_172 VGND VGND VPWR VPWR sky130_fd_sc_hd__fill_2
XFILLER_31_356 VGND VGND VPWR VPWR sky130_fd_sc_hd__decap_3
XFILLER_12_581 VGND VGND VPWR VPWR sky130_fd_sc_hd__decap_3
XFILLER_12_592 VGND VGND VPWR VPWR sky130_fd_sc_hd__decap_3
XFILLER_61_80 VGND VGND VPWR VPWR sky130_fd_sc_hd__fill_1
XFILLER_8_563 VGND VGND VPWR VPWR sky130_fd_sc_hd__decap_3
XANTENNA_2 _7366_/Q VGND VGND VPWR VPWR sky130_fd_sc_hd__diode_2
X_4430_ _7239_/Q _4430_/A2 _4459_/C1 _7175_/Q _4429_/X VGND VGND VPWR VPWR _4430_/X
+ sky130_fd_sc_hd__a221o_2
XFILLER_6_64 VGND VGND VPWR VPWR sky130_fd_sc_hd__decap_3
XFILLER_113_612 VGND VGND VPWR VPWR sky130_fd_sc_hd__decap_3
XFILLER_113_623 VGND VGND VPWR VPWR sky130_fd_sc_hd__decap_3
X_4361_ _5086_/A _4619_/B _5101_/B _5073_/A VGND VGND VPWR VPWR _4361_/X sky130_fd_sc_hd__and4_2
XFILLER_98_323 VGND VGND VPWR VPWR sky130_fd_sc_hd__decap_3
XFILLER_98_301 VGND VGND VPWR VPWR sky130_fd_sc_hd__decap_3
XFILLER_113_656 VGND VGND VPWR VPWR sky130_fd_sc_hd__decap_3
X_7080_ _7395_/CLK _7080_/D _6360_/Y VGND VGND VPWR VPWR _7080_/Q sky130_fd_sc_hd__dfrtp_2
X_4292_ _4292_/A _4292_/B _4292_/C VGND VGND VPWR VPWR _4292_/X sky130_fd_sc_hd__and3_2
X_3312_ _5129_/A _4467_/A _3519_/B _3310_/Y _5671_/A VGND VGND VPWR VPWR _5646_/A
+ sky130_fd_sc_hd__a311o_2
XFILLER_98_334 VGND VGND VPWR VPWR sky130_fd_sc_hd__fill_1
XFILLER_79_570 VGND VGND VPWR VPWR sky130_fd_sc_hd__decap_3
XFILLER_98_389 VGND VGND VPWR VPWR sky130_fd_sc_hd__decap_3
XFILLER_100_339 VGND VGND VPWR VPWR sky130_fd_sc_hd__decap_3
XFILLER_39_445 VGND VGND VPWR VPWR sky130_fd_sc_hd__decap_3
XFILLER_66_253 VGND VGND VPWR VPWR sky130_fd_sc_hd__decap_3
XFILLER_94_551 VGND VGND VPWR VPWR sky130_fd_sc_hd__decap_3
XFILLER_27_629 VGND VGND VPWR VPWR sky130_fd_sc_hd__decap_3
XFILLER_94_584 VGND VGND VPWR VPWR sky130_fd_sc_hd__decap_3
XFILLER_94_595 VGND VGND VPWR VPWR sky130_fd_sc_hd__decap_3
XFILLER_19_180 VGND VGND VPWR VPWR sky130_fd_sc_hd__decap_3
XFILLER_81_234 VGND VGND VPWR VPWR sky130_fd_sc_hd__decap_3
X_6933_ _6941_/CLK _6933_/D VGND VGND VPWR VPWR _6933_/Q sky130_fd_sc_hd__dfxtp_2
XFILLER_35_662 VGND VGND VPWR VPWR sky130_fd_sc_hd__decap_3
XFILLER_35_673 VGND VGND VPWR VPWR sky130_fd_sc_hd__decap_3
XFILLER_50_610 VGND VGND VPWR VPWR sky130_fd_sc_hd__decap_3
XFILLER_81_278 VGND VGND VPWR VPWR sky130_fd_sc_hd__fill_2
X_6864_ _6966_/CLK _6864_/D VGND VGND VPWR VPWR _6864_/Q sky130_fd_sc_hd__dfxtp_2
XFILLER_22_312 VGND VGND VPWR VPWR sky130_fd_sc_hd__decap_3
XFILLER_22_323 VGND VGND VPWR VPWR sky130_fd_sc_hd__decap_3
XFILLER_50_643 VGND VGND VPWR VPWR sky130_fd_sc_hd__fill_1
XFILLER_50_654 VGND VGND VPWR VPWR sky130_fd_sc_hd__decap_3
X_6795_ _6943_/CLK _6795_/D VGND VGND VPWR VPWR _6795_/Q sky130_fd_sc_hd__dfxtp_2
XFILLER_10_529 VGND VGND VPWR VPWR sky130_fd_sc_hd__decap_3
XFILLER_50_687 VGND VGND VPWR VPWR sky130_fd_sc_hd__decap_3
XFILLER_108_439 VGND VGND VPWR VPWR sky130_fd_sc_hd__decap_3
X_4628_ _4628_/A VGND VGND VPWR VPWR _4629_/A sky130_fd_sc_hd__inv_2
XFILLER_104_601 VGND VGND VPWR VPWR sky130_fd_sc_hd__decap_3
XFILLER_116_483 VGND VGND VPWR VPWR sky130_fd_sc_hd__decap_3
XFILLER_89_312 VGND VGND VPWR VPWR sky130_fd_sc_hd__decap_3
X_7347_ _7350_/CLK _7347_/D _6627_/Y VGND VGND VPWR VPWR _7347_/Q sky130_fd_sc_hd__dfrtp_2
X_4559_ _7301_/Q _4563_/B VGND VGND VPWR VPWR _7301_/D sky130_fd_sc_hd__and2_2
XFILLER_103_122 VGND VGND VPWR VPWR sky130_fd_sc_hd__decap_3
XFILLER_104_634 VGND VGND VPWR VPWR sky130_fd_sc_hd__decap_3
XFILLER_104_645 VGND VGND VPWR VPWR sky130_fd_sc_hd__decap_3
XFILLER_1_249 VGND VGND VPWR VPWR sky130_fd_sc_hd__fill_1
XFILLER_89_356 VGND VGND VPWR VPWR sky130_fd_sc_hd__decap_3
X_7278_ _7374_/CLK _7278_/D _6558_/Y VGND VGND VPWR VPWR _7278_/Q sky130_fd_sc_hd__dfrtp_2
Xhold585 _6786_/Q VGND VGND VPWR VPWR _6786_/D sky130_fd_sc_hd__dlygate4sd3_1
Xhold596 _6890_/Q VGND VGND VPWR VPWR _6890_/D sky130_fd_sc_hd__dlygate4sd3_1
XFILLER_104_678 VGND VGND VPWR VPWR sky130_fd_sc_hd__decap_3
XFILLER_106_32 VGND VGND VPWR VPWR sky130_fd_sc_hd__decap_3
XFILLER_89_389 VGND VGND VPWR VPWR sky130_fd_sc_hd__decap_3
XFILLER_103_199 VGND VGND VPWR VPWR sky130_fd_sc_hd__decap_3
XFILLER_18_607 VGND VGND VPWR VPWR sky130_fd_sc_hd__decap_3
XFILLER_85_551 VGND VGND VPWR VPWR sky130_fd_sc_hd__decap_3
XFILLER_45_426 VGND VGND VPWR VPWR sky130_fd_sc_hd__decap_3
XFILLER_57_264 VGND VGND VPWR VPWR sky130_fd_sc_hd__decap_3
XFILLER_72_212 VGND VGND VPWR VPWR sky130_fd_sc_hd__decap_3
XFILLER_85_573 VGND VGND VPWR VPWR sky130_fd_sc_hd__decap_3
XTAP_TAPCELL_ROW_56_922 VGND VPWR sky130_fd_sc_hd__tapvpwrvgnd_1
XFILLER_26_640 VGND VGND VPWR VPWR sky130_fd_sc_hd__decap_3
XFILLER_72_245 VGND VGND VPWR VPWR sky130_fd_sc_hd__decap_3
XFILLER_25_150 VGND VGND VPWR VPWR sky130_fd_sc_hd__fill_1
XFILLER_26_651 VGND VGND VPWR VPWR sky130_fd_sc_hd__decap_3
XFILLER_26_684 VGND VGND VPWR VPWR sky130_fd_sc_hd__decap_3
XFILLER_72_256 VGND VGND VPWR VPWR sky130_fd_sc_hd__decap_3
XFILLER_82_24 VGND VGND VPWR VPWR sky130_fd_sc_hd__decap_3
XFILLER_13_334 VGND VGND VPWR VPWR sky130_fd_sc_hd__fill_2
XFILLER_41_632 VGND VGND VPWR VPWR sky130_fd_sc_hd__decap_3
XFILLER_53_470 VGND VGND VPWR VPWR sky130_fd_sc_hd__decap_3
XFILLER_82_68 VGND VGND VPWR VPWR sky130_fd_sc_hd__decap_3
XFILLER_15_84 VGND VGND VPWR VPWR sky130_fd_sc_hd__decap_3
XFILLER_41_665 VGND VGND VPWR VPWR sky130_fd_sc_hd__decap_3
XFILLER_41_676 VGND VGND VPWR VPWR sky130_fd_sc_hd__decap_3
XFILLER_40_197 VGND VGND VPWR VPWR sky130_fd_sc_hd__decap_3
XTAP_TAPCELL_ROW_97_1412 VGND VPWR sky130_fd_sc_hd__tapvpwrvgnd_1
XFILLER_5_511 VGND VGND VPWR VPWR sky130_fd_sc_hd__decap_3
XFILLER_5_544 VGND VGND VPWR VPWR sky130_fd_sc_hd__decap_3
XFILLER_107_461 VGND VGND VPWR VPWR sky130_fd_sc_hd__decap_3
XFILLER_5_588 VGND VGND VPWR VPWR sky130_fd_sc_hd__decap_3
XFILLER_107_494 VGND VGND VPWR VPWR sky130_fd_sc_hd__decap_3
XFILLER_110_604 VGND VGND VPWR VPWR sky130_fd_sc_hd__decap_3
XFILLER_95_315 VGND VGND VPWR VPWR sky130_fd_sc_hd__fill_1
XFILLER_110_637 VGND VGND VPWR VPWR sky130_fd_sc_hd__decap_3
XFILLER_110_648 VGND VGND VPWR VPWR sky130_fd_sc_hd__decap_3
XFILLER_95_348 VGND VGND VPWR VPWR sky130_fd_sc_hd__decap_3
XFILLER_48_231 VGND VGND VPWR VPWR sky130_fd_sc_hd__fill_1
XFILLER_48_253 VGND VGND VPWR VPWR sky130_fd_sc_hd__decap_3
XFILLER_76_551 VGND VGND VPWR VPWR sky130_fd_sc_hd__decap_3
XFILLER_36_404 VGND VGND VPWR VPWR sky130_fd_sc_hd__decap_3
XFILLER_76_584 VGND VGND VPWR VPWR sky130_fd_sc_hd__decap_3
XFILLER_76_595 VGND VGND VPWR VPWR sky130_fd_sc_hd__decap_3
XFILLER_63_234 VGND VGND VPWR VPWR sky130_fd_sc_hd__decap_3
XFILLER_91_543 VGND VGND VPWR VPWR sky130_fd_sc_hd__decap_3
XFILLER_17_662 VGND VGND VPWR VPWR sky130_fd_sc_hd__decap_3
XFILLER_17_673 VGND VGND VPWR VPWR sky130_fd_sc_hd__decap_3
XFILLER_51_418 VGND VGND VPWR VPWR sky130_fd_sc_hd__decap_3
XFILLER_63_267 VGND VGND VPWR VPWR sky130_fd_sc_hd__decap_3
XFILLER_91_576 VGND VGND VPWR VPWR sky130_fd_sc_hd__decap_3
XFILLER_32_610 VGND VGND VPWR VPWR sky130_fd_sc_hd__decap_3
Xplace289 _5660_/B VGND VGND VPWR VPWR _3890_/B1 sky130_fd_sc_hd__buf_2
Xplace278 _3665_/X VGND VGND VPWR VPWR _3887_/B1 sky130_fd_sc_hd__buf_2
Xplace267 _4907_/Y VGND VGND VPWR VPWR _5657_/B sky130_fd_sc_hd__buf_2
XFILLER_32_643 VGND VGND VPWR VPWR sky130_fd_sc_hd__fill_1
XFILLER_32_654 VGND VGND VPWR VPWR sky130_fd_sc_hd__decap_3
XFILLER_32_687 VGND VGND VPWR VPWR sky130_fd_sc_hd__decap_3
XFILLER_82_3 VGND VGND VPWR VPWR sky130_fd_sc_hd__decap_3
X_6580_ _6612_/A VGND VGND VPWR VPWR _6580_/Y sky130_fd_sc_hd__inv_2
X_5600_ _5600_/A _5634_/B VGND VGND VPWR VPWR _7027_/D sky130_fd_sc_hd__and2_2
X_3792_ hold945/X _3822_/A2 _4961_/A VGND VGND VPWR VPWR _7392_/D sky130_fd_sc_hd__a21o_2
XFILLER_105_409 VGND VGND VPWR VPWR sky130_fd_sc_hd__fill_2
XFILLER_8_393 VGND VGND VPWR VPWR sky130_fd_sc_hd__decap_3
X_7201_ _7395_/CLK _7201_/D _6481_/Y VGND VGND VPWR VPWR _7201_/Q sky130_fd_sc_hd__dfrtp_2
X_4413_ _4413_/A VGND VGND VPWR VPWR _4787_/A sky130_fd_sc_hd__inv_2
XFILLER_113_420 VGND VGND VPWR VPWR sky130_fd_sc_hd__decap_3
X_7132_ _7328_/CLK _7132_/D _6412_/Y VGND VGND VPWR VPWR _7132_/Q sky130_fd_sc_hd__dfrtp_2
X_4344_ _4365_/A _4365_/B _4365_/C VGND VGND VPWR VPWR _4345_/B sky130_fd_sc_hd__a21bo_2
XFILLER_99_632 VGND VGND VPWR VPWR sky130_fd_sc_hd__decap_3
XFILLER_101_615 VGND VGND VPWR VPWR sky130_fd_sc_hd__fill_1
XFILLER_113_464 VGND VGND VPWR VPWR sky130_fd_sc_hd__decap_3
X_7063_ _7344_/CLK _7063_/D _6343_/Y VGND VGND VPWR VPWR _7063_/Q sky130_fd_sc_hd__dfrtp_2
XTAP_TAPCELL_ROW_6_319 VGND VPWR sky130_fd_sc_hd__tapvpwrvgnd_1
XFILLER_99_676 VGND VGND VPWR VPWR sky130_fd_sc_hd__decap_3
XFILLER_99_665 VGND VGND VPWR VPWR sky130_fd_sc_hd__decap_3
XFILLER_100_114 VGND VGND VPWR VPWR sky130_fd_sc_hd__decap_3
XFILLER_101_626 VGND VGND VPWR VPWR sky130_fd_sc_hd__decap_3
XFILLER_113_497 VGND VGND VPWR VPWR sky130_fd_sc_hd__decap_3
XFILLER_86_315 VGND VGND VPWR VPWR sky130_fd_sc_hd__decap_3
X_4275_ _4275_/A _4274_/Y VGND VGND VPWR VPWR _4275_/Y sky130_fd_sc_hd__nor2b_2
XFILLER_101_659 VGND VGND VPWR VPWR sky130_fd_sc_hd__decap_3
XFILLER_86_359 VGND VGND VPWR VPWR sky130_fd_sc_hd__decap_3
XFILLER_100_169 VGND VGND VPWR VPWR sky130_fd_sc_hd__decap_3
XFILLER_54_212 VGND VGND VPWR VPWR sky130_fd_sc_hd__decap_3
XFILLER_67_573 VGND VGND VPWR VPWR sky130_fd_sc_hd__decap_3
XFILLER_39_297 VGND VGND VPWR VPWR sky130_fd_sc_hd__decap_3
XFILLER_82_554 VGND VGND VPWR VPWR sky130_fd_sc_hd__decap_3
XFILLER_42_418 VGND VGND VPWR VPWR sky130_fd_sc_hd__fill_2
XFILLER_54_278 VGND VGND VPWR VPWR sky130_fd_sc_hd__decap_3
XFILLER_82_587 VGND VGND VPWR VPWR sky130_fd_sc_hd__fill_1
XTAP_TAPCELL_ROW_68_1068 VGND VPWR sky130_fd_sc_hd__tapvpwrvgnd_1
XFILLER_23_632 VGND VGND VPWR VPWR sky130_fd_sc_hd__decap_3
XFILLER_35_470 VGND VGND VPWR VPWR sky130_fd_sc_hd__fill_1
XFILLER_82_598 VGND VGND VPWR VPWR sky130_fd_sc_hd__decap_3
X_6916_ _7378_/CLK _6916_/D VGND VGND VPWR VPWR _6916_/Q sky130_fd_sc_hd__dfxtp_2
XTAP_TAPCELL_ROW_81_1224 VGND VPWR sky130_fd_sc_hd__tapvpwrvgnd_1
XFILLER_23_665 VGND VGND VPWR VPWR sky130_fd_sc_hd__decap_3
XFILLER_23_676 VGND VGND VPWR VPWR sky130_fd_sc_hd__decap_3
XFILLER_52_38 VGND VGND VPWR VPWR sky130_fd_sc_hd__fill_2
X_6847_ clkload9/A _6847_/D VGND VGND VPWR VPWR _6847_/Q sky130_fd_sc_hd__dfxtp_2
XFILLER_10_315 VGND VGND VPWR VPWR sky130_fd_sc_hd__decap_3
XFILLER_50_473 VGND VGND VPWR VPWR sky130_fd_sc_hd__decap_3
X_6778_ _7378_/CLK _6778_/D VGND VGND VPWR VPWR _6778_/Q sky130_fd_sc_hd__dfxtp_2
XTAP_TAPCELL_ROW_61_980 VGND VPWR sky130_fd_sc_hd__tapvpwrvgnd_1
XFILLER_10_337 VGND VGND VPWR VPWR sky130_fd_sc_hd__decap_3
XFILLER_22_186 VGND VGND VPWR VPWR sky130_fd_sc_hd__decap_3
XFILLER_22_197 VGND VGND VPWR VPWR sky130_fd_sc_hd__decap_3
X_5729_ _7370_/Q hold919/X _5735_/S VGND VGND VPWR VPWR _6714_/D sky130_fd_sc_hd__mux2_2
XTAP_TAPCELL_ROW_79_1197 VGND VPWR sky130_fd_sc_hd__tapvpwrvgnd_1
XFILLER_2_525 VGND VGND VPWR VPWR sky130_fd_sc_hd__decap_3
XFILLER_2_536 VGND VGND VPWR VPWR sky130_fd_sc_hd__decap_3
XFILLER_89_131 VGND VGND VPWR VPWR sky130_fd_sc_hd__decap_3
XTAP_TAPCELL_ROW_92_1353 VGND VPWR sky130_fd_sc_hd__tapvpwrvgnd_1
XFILLER_2_569 VGND VGND VPWR VPWR sky130_fd_sc_hd__decap_3
XFILLER_77_46 VGND VGND VPWR VPWR sky130_fd_sc_hd__fill_2
XFILLER_104_475 VGND VGND VPWR VPWR sky130_fd_sc_hd__fill_1
XFILLER_104_486 VGND VGND VPWR VPWR sky130_fd_sc_hd__decap_3
XFILLER_77_68 VGND VGND VPWR VPWR sky130_fd_sc_hd__decap_3
XFILLER_89_175 VGND VGND VPWR VPWR sky130_fd_sc_hd__fill_1
XFILLER_77_359 VGND VGND VPWR VPWR sky130_fd_sc_hd__decap_3
XFILLER_100_681 VGND VGND VPWR VPWR sky130_fd_sc_hd__decap_3
XFILLER_58_595 VGND VGND VPWR VPWR sky130_fd_sc_hd__decap_3
XFILLER_93_12 VGND VGND VPWR VPWR sky130_fd_sc_hd__decap_3
Xhold1060 _7316_/Q VGND VGND VPWR VPWR _4526_/A0 sky130_fd_sc_hd__dlygate4sd3_1
Xhold1071 _7342_/Q VGND VGND VPWR VPWR _4474_/A0 sky130_fd_sc_hd__dlygate4sd3_1
Xhold1082 _7252_/Q VGND VGND VPWR VPWR _5132_/A0 sky130_fd_sc_hd__dlygate4sd3_1
Xhold1093 _7120_/Q VGND VGND VPWR VPWR _5427_/A0 sky130_fd_sc_hd__dlygate4sd3_1
XFILLER_73_576 VGND VGND VPWR VPWR sky130_fd_sc_hd__decap_3
XFILLER_14_610 VGND VGND VPWR VPWR sky130_fd_sc_hd__decap_3
XFILLER_26_83 VGND VGND VPWR VPWR sky130_fd_sc_hd__fill_1
XFILLER_33_429 VGND VGND VPWR VPWR sky130_fd_sc_hd__decap_3
XFILLER_45_289 VGND VGND VPWR VPWR sky130_fd_sc_hd__decap_3
XFILLER_14_643 VGND VGND VPWR VPWR sky130_fd_sc_hd__fill_1
XFILLER_14_654 VGND VGND VPWR VPWR sky130_fd_sc_hd__decap_3
XFILLER_60_259 VGND VGND VPWR VPWR sky130_fd_sc_hd__decap_3
XFILLER_13_153 VGND VGND VPWR VPWR sky130_fd_sc_hd__decap_3
XFILLER_13_164 VGND VGND VPWR VPWR sky130_fd_sc_hd__decap_3
XFILLER_13_175 VGND VGND VPWR VPWR sky130_fd_sc_hd__decap_3
XFILLER_14_687 VGND VGND VPWR VPWR sky130_fd_sc_hd__decap_3
XFILLER_41_473 VGND VGND VPWR VPWR sky130_fd_sc_hd__decap_3
XFILLER_41_484 VGND VGND VPWR VPWR sky130_fd_sc_hd__fill_1
XTAP_TAPCELL_ROW_31_619 VGND VPWR sky130_fd_sc_hd__tapvpwrvgnd_1
XTAP_TAPCELL_ROW_101_1460 VGND VPWR sky130_fd_sc_hd__tapvpwrvgnd_1
XFILLER_42_71 VGND VGND VPWR VPWR sky130_fd_sc_hd__decap_3
XTAP_TAPCELL_ROW_11_387 VGND VPWR sky130_fd_sc_hd__tapvpwrvgnd_1
XFILLER_47_6 VGND VGND VPWR VPWR sky130_fd_sc_hd__fill_1
XFILLER_3_21 VGND VGND VPWR VPWR sky130_fd_sc_hd__decap_3
XFILLER_96_613 VGND VGND VPWR VPWR sky130_fd_sc_hd__decap_3
XFILLER_1_580 VGND VGND VPWR VPWR sky130_fd_sc_hd__decap_3
XFILLER_68_337 VGND VGND VPWR VPWR sky130_fd_sc_hd__decap_3
XFILLER_95_123 VGND VGND VPWR VPWR sky130_fd_sc_hd__decap_3
XFILLER_110_445 VGND VGND VPWR VPWR sky130_fd_sc_hd__decap_3
XFILLER_96_657 VGND VGND VPWR VPWR sky130_fd_sc_hd__decap_3
X_4060_ _7084_/Q _4102_/B _4432_/B1 _4059_/X VGND VGND VPWR VPWR _4068_/A sky130_fd_sc_hd__o211a_2
XFILLER_110_489 VGND VGND VPWR VPWR sky130_fd_sc_hd__decap_3
XFILLER_49_573 VGND VGND VPWR VPWR sky130_fd_sc_hd__decap_3
XTAP_TAPCELL_ROW_39_719 VGND VPWR sky130_fd_sc_hd__tapvpwrvgnd_1
XFILLER_36_212 VGND VGND VPWR VPWR sky130_fd_sc_hd__decap_3
XFILLER_36_245 VGND VGND VPWR VPWR sky130_fd_sc_hd__decap_3
XFILLER_36_256 VGND VGND VPWR VPWR sky130_fd_sc_hd__decap_3
XFILLER_64_554 VGND VGND VPWR VPWR sky130_fd_sc_hd__decap_3
XFILLER_64_587 VGND VGND VPWR VPWR sky130_fd_sc_hd__fill_1
XFILLER_91_340 VGND VGND VPWR VPWR sky130_fd_sc_hd__fill_1
XFILLER_17_492 VGND VGND VPWR VPWR sky130_fd_sc_hd__decap_3
XFILLER_24_429 VGND VGND VPWR VPWR sky130_fd_sc_hd__decap_3
XFILLER_64_598 VGND VGND VPWR VPWR sky130_fd_sc_hd__decap_3
X_4962_ _6994_/Q _4977_/A VGND VGND VPWR VPWR _4963_/B sky130_fd_sc_hd__nor2_2
XTAP_TAPCELL_ROW_19_476 VGND VPWR sky130_fd_sc_hd__tapvpwrvgnd_1
XFILLER_32_451 VGND VGND VPWR VPWR sky130_fd_sc_hd__decap_3
XFILLER_51_248 VGND VGND VPWR VPWR sky130_fd_sc_hd__decap_3
X_6701_ _6966_/CLK _6701_/D VGND VGND VPWR VPWR _6701_/Q sky130_fd_sc_hd__dfxtp_2
X_4893_ _4928_/B _4943_/A _6996_/Q VGND VGND VPWR VPWR _4908_/B sky130_fd_sc_hd__o21a_2
X_3913_ _6857_/Q _3922_/A2 _3913_/B1 _6849_/Q _3912_/X VGND VGND VPWR VPWR _3913_/X
+ sky130_fd_sc_hd__a221o_2
XFILLER_20_613 VGND VGND VPWR VPWR sky130_fd_sc_hd__decap_3
X_6632_ _6632_/A VGND VGND VPWR VPWR _6632_/Y sky130_fd_sc_hd__inv_2
X_3844_ _3741_/X _3841_/X _3843_/X _3629_/A VGND VGND VPWR VPWR _3845_/B sky130_fd_sc_hd__a22o_2
XFILLER_20_657 VGND VGND VPWR VPWR sky130_fd_sc_hd__decap_3
X_6563_ _6566_/A VGND VGND VPWR VPWR _6563_/Y sky130_fd_sc_hd__inv_2
X_3775_ _3714_/X _3772_/X _3774_/X _3733_/X VGND VGND VPWR VPWR _3775_/X sky130_fd_sc_hd__a22o_2
X_6494_ _6494_/A VGND VGND VPWR VPWR _6494_/Y sky130_fd_sc_hd__inv_2
XTAP_TAPCELL_ROW_115_1629 VGND VPWR sky130_fd_sc_hd__tapvpwrvgnd_1
XFILLER_105_228 VGND VGND VPWR VPWR sky130_fd_sc_hd__decap_3
X_7115_ _7307_/CLK _7115_/D _6395_/Y VGND VGND VPWR VPWR _7115_/Q sky130_fd_sc_hd__dfrtp_2
Xoutput487 _3741_/B VGND VGND VPWR VPWR alu_result_out[6] sky130_fd_sc_hd__clkdlybuf4s25_1
Xoutput476 _5663_/B VGND VGND VPWR VPWR alu_result_out[25] sky130_fd_sc_hd__clkdlybuf4s25_1
Xoutput465 _5657_/D VGND VGND VPWR VPWR alu_result_out[15] sky130_fd_sc_hd__clkdlybuf4s25_1
XFILLER_101_401 VGND VGND VPWR VPWR sky130_fd_sc_hd__decap_3
XFILLER_59_337 VGND VGND VPWR VPWR sky130_fd_sc_hd__decap_3
XFILLER_86_112 VGND VGND VPWR VPWR sky130_fd_sc_hd__decap_3
XFILLER_87_635 VGND VGND VPWR VPWR sky130_fd_sc_hd__decap_3
Xoutput498 _5641_/Y VGND VGND VPWR VPWR instruction_out[17] sky130_fd_sc_hd__clkdlybuf4s25_1
X_4327_ _4327_/A _4327_/B VGND VGND VPWR VPWR _4362_/C sky130_fd_sc_hd__nand2_2
XFILLER_99_495 VGND VGND VPWR VPWR sky130_fd_sc_hd__decap_3
XFILLER_113_294 VGND VGND VPWR VPWR sky130_fd_sc_hd__decap_3
XFILLER_87_668 VGND VGND VPWR VPWR sky130_fd_sc_hd__decap_3
XFILLER_87_679 VGND VGND VPWR VPWR sky130_fd_sc_hd__decap_3
X_7046_ _7395_/CLK _7046_/D _6326_/Y VGND VGND VPWR VPWR _7046_/Q sky130_fd_sc_hd__dfrtp_2
X_4258_ _4988_/A _4988_/B VGND VGND VPWR VPWR _5003_/A sky130_fd_sc_hd__or2_4
XFILLER_101_489 VGND VGND VPWR VPWR sky130_fd_sc_hd__decap_3
XFILLER_74_318 VGND VGND VPWR VPWR sky130_fd_sc_hd__decap_3
X_4189_ _7231_/Q _4421_/A2 _4348_/A2 _7167_/Q _4188_/X VGND VGND VPWR VPWR _4189_/X
+ sky130_fd_sc_hd__a221o_2
XFILLER_55_576 VGND VGND VPWR VPWR sky130_fd_sc_hd__decap_3
XFILLER_63_15 VGND VGND VPWR VPWR sky130_fd_sc_hd__decap_3
XFILLER_42_204 VGND VGND VPWR VPWR sky130_fd_sc_hd__decap_3
XFILLER_63_48 VGND VGND VPWR VPWR sky130_fd_sc_hd__decap_3
XFILLER_70_546 VGND VGND VPWR VPWR sky130_fd_sc_hd__decap_3
XFILLER_42_248 VGND VGND VPWR VPWR sky130_fd_sc_hd__decap_3
XFILLER_70_579 VGND VGND VPWR VPWR sky130_fd_sc_hd__decap_3
XFILLER_23_473 VGND VGND VPWR VPWR sky130_fd_sc_hd__fill_1
XFILLER_11_635 VGND VGND VPWR VPWR sky130_fd_sc_hd__decap_3
XFILLER_7_606 VGND VGND VPWR VPWR sky130_fd_sc_hd__decap_3
XFILLER_109_523 VGND VGND VPWR VPWR sky130_fd_sc_hd__decap_3
XFILLER_11_668 VGND VGND VPWR VPWR sky130_fd_sc_hd__decap_3
XFILLER_11_679 VGND VGND VPWR VPWR sky130_fd_sc_hd__decap_3
XFILLER_7_617 VGND VGND VPWR VPWR sky130_fd_sc_hd__decap_3
XFILLER_109_556 VGND VGND VPWR VPWR sky130_fd_sc_hd__decap_3
XFILLER_109_567 VGND VGND VPWR VPWR sky130_fd_sc_hd__decap_3
Xwire559 _3576_/Y VGND VGND VPWR VPWR _3591_/B sky130_fd_sc_hd__clkbuf_2
XFILLER_2_300 VGND VGND VPWR VPWR sky130_fd_sc_hd__decap_3
XFILLER_78_613 VGND VGND VPWR VPWR sky130_fd_sc_hd__decap_3
XFILLER_77_156 VGND VGND VPWR VPWR sky130_fd_sc_hd__fill_2
XFILLER_78_657 VGND VGND VPWR VPWR sky130_fd_sc_hd__decap_3
XFILLER_92_104 VGND VGND VPWR VPWR sky130_fd_sc_hd__decap_3
XFILLER_93_638 VGND VGND VPWR VPWR sky130_fd_sc_hd__decap_3
XFILLER_37_60 VGND VGND VPWR VPWR sky130_fd_sc_hd__decap_3
XFILLER_58_392 VGND VGND VPWR VPWR sky130_fd_sc_hd__decap_3
XFILLER_86_690 VGND VGND VPWR VPWR sky130_fd_sc_hd__fill_1
XFILLER_37_71 VGND VGND VPWR VPWR sky130_fd_sc_hd__decap_3
XFILLER_46_576 VGND VGND VPWR VPWR sky130_fd_sc_hd__decap_3
XFILLER_73_340 VGND VGND VPWR VPWR sky130_fd_sc_hd__decap_3
XPHY_EDGE_ROW_16_Right_16 VGND VGND VPWR VPWR sky130_fd_sc_hd__decap_3
XFILLER_18_289 VGND VGND VPWR VPWR sky130_fd_sc_hd__decap_3
XFILLER_33_215 VGND VGND VPWR VPWR sky130_fd_sc_hd__decap_3
XFILLER_46_598 VGND VGND VPWR VPWR sky130_fd_sc_hd__decap_3
XFILLER_33_237 VGND VGND VPWR VPWR sky130_fd_sc_hd__decap_3
XFILLER_61_557 VGND VGND VPWR VPWR sky130_fd_sc_hd__decap_3
XFILLER_61_579 VGND VGND VPWR VPWR sky130_fd_sc_hd__decap_3
XTAP_TAPCELL_ROW_16_446 VGND VPWR sky130_fd_sc_hd__tapvpwrvgnd_1
XTAP_TAPCELL_ROW_44_777 VGND VPWR sky130_fd_sc_hd__tapvpwrvgnd_1
XFILLER_41_281 VGND VGND VPWR VPWR sky130_fd_sc_hd__decap_3
XFILLER_53_92 VGND VGND VPWR VPWR sky130_fd_sc_hd__decap_3
XFILLER_10_690 VGND VGND VPWR VPWR sky130_fd_sc_hd__fill_1
X_3560_ _5118_/D _3560_/B VGND VGND VPWR VPWR _3562_/B sky130_fd_sc_hd__nor2_2
XPHY_EDGE_ROW_25_Right_25 VGND VGND VPWR VPWR sky130_fd_sc_hd__decap_3
XFILLER_6_672 VGND VGND VPWR VPWR sky130_fd_sc_hd__decap_3
XFILLER_115_526 VGND VGND VPWR VPWR sky130_fd_sc_hd__decap_3
XFILLER_115_559 VGND VGND VPWR VPWR sky130_fd_sc_hd__fill_1
X_3491_ _7215_/Q _3377_/X _3366_/X _7151_/Q _3490_/X VGND VGND VPWR VPWR _3491_/X
+ sky130_fd_sc_hd__a221o_2
XFILLER_45_3 VGND VGND VPWR VPWR sky130_fd_sc_hd__decap_3
XFILLER_5_193 VGND VGND VPWR VPWR sky130_fd_sc_hd__decap_3
XFILLER_69_635 VGND VGND VPWR VPWR sky130_fd_sc_hd__decap_3
X_5161_ _5161_/A _5641_/A VGND VGND VPWR VPWR _5190_/B sky130_fd_sc_hd__or2_2
XFILLER_110_231 VGND VGND VPWR VPWR sky130_fd_sc_hd__fill_1
XFILLER_68_134 VGND VGND VPWR VPWR sky130_fd_sc_hd__decap_3
XFILLER_69_668 VGND VGND VPWR VPWR sky130_fd_sc_hd__decap_3
XFILLER_69_679 VGND VGND VPWR VPWR sky130_fd_sc_hd__decap_3
XFILLER_96_432 VGND VGND VPWR VPWR sky130_fd_sc_hd__decap_3
X_5092_ _5069_/B _5092_/B _5092_/C VGND VGND VPWR VPWR _5092_/X sky130_fd_sc_hd__and3b_2
X_4112_ _7332_/Q _3964_/S _4505_/S _7300_/Q VGND VGND VPWR VPWR _4112_/X sky130_fd_sc_hd__a22o_2
XFILLER_56_318 VGND VGND VPWR VPWR sky130_fd_sc_hd__decap_3
XFILLER_68_156 VGND VGND VPWR VPWR sky130_fd_sc_hd__decap_3
XFILLER_68_189 VGND VGND VPWR VPWR sky130_fd_sc_hd__decap_3
XFILLER_84_616 VGND VGND VPWR VPWR sky130_fd_sc_hd__decap_3
X_4043_ _7309_/Q _4478_/S _4459_/C1 _7181_/Q _4042_/X VGND VGND VPWR VPWR _4043_/X
+ sky130_fd_sc_hd__a221o_2
XPHY_EDGE_ROW_34_Right_34 VGND VGND VPWR VPWR sky130_fd_sc_hd__decap_3
XFILLER_37_576 VGND VGND VPWR VPWR sky130_fd_sc_hd__decap_3
XFILLER_92_660 VGND VGND VPWR VPWR sky130_fd_sc_hd__decap_3
XTAP_TAPCELL_ROW_65_1027 VGND VPWR sky130_fd_sc_hd__tapvpwrvgnd_1
XFILLER_24_259 VGND VGND VPWR VPWR sky130_fd_sc_hd__decap_3
XFILLER_52_568 VGND VGND VPWR VPWR sky130_fd_sc_hd__decap_3
X_4945_ _5040_/S _6995_/D _5657_/C _4944_/X VGND VGND VPWR VPWR _4945_/X sky130_fd_sc_hd__o22a_2
XFILLER_32_281 VGND VGND VPWR VPWR sky130_fd_sc_hd__decap_3
XFILLER_20_443 VGND VGND VPWR VPWR sky130_fd_sc_hd__decap_3
X_6615_ _6617_/A VGND VGND VPWR VPWR _6615_/Y sky130_fd_sc_hd__inv_2
X_3827_ _6700_/Q _3913_/B1 _3922_/B1 _6878_/Q VGND VGND VPWR VPWR _3827_/X sky130_fd_sc_hd__a22o_2
XPHY_EDGE_ROW_43_Right_43 VGND VGND VPWR VPWR sky130_fd_sc_hd__decap_3
X_6546_ _6643_/A VGND VGND VPWR VPWR _6546_/Y sky130_fd_sc_hd__inv_2
XFILLER_106_504 VGND VGND VPWR VPWR sky130_fd_sc_hd__decap_3
XFILLER_106_548 VGND VGND VPWR VPWR sky130_fd_sc_hd__decap_3
X_6477_ _6537_/A VGND VGND VPWR VPWR _6477_/Y sky130_fd_sc_hd__inv_2
XTAP_TAPCELL_ROW_76_1167 VGND VPWR sky130_fd_sc_hd__tapvpwrvgnd_1
XFILLER_114_581 VGND VGND VPWR VPWR sky130_fd_sc_hd__decap_3
XFILLER_99_281 VGND VGND VPWR VPWR sky130_fd_sc_hd__fill_1
XFILLER_99_270 VGND VGND VPWR VPWR sky130_fd_sc_hd__fill_1
XFILLER_101_220 VGND VGND VPWR VPWR sky130_fd_sc_hd__decap_3
XFILLER_114_592 VGND VGND VPWR VPWR sky130_fd_sc_hd__decap_3
XFILLER_58_59 VGND VGND VPWR VPWR sky130_fd_sc_hd__decap_3
XFILLER_101_275 VGND VGND VPWR VPWR sky130_fd_sc_hd__decap_3
XFILLER_114_21 VGND VGND VPWR VPWR sky130_fd_sc_hd__decap_3
XFILLER_114_32 VGND VGND VPWR VPWR sky130_fd_sc_hd__decap_3
XFILLER_47_329 VGND VGND VPWR VPWR sky130_fd_sc_hd__fill_1
XFILLER_75_638 VGND VGND VPWR VPWR sky130_fd_sc_hd__decap_3
X_7029_ _7344_/CLK _7029_/D _6309_/Y VGND VGND VPWR VPWR _7029_/Q sky130_fd_sc_hd__dfrtp_2
XPHY_EDGE_ROW_52_Right_52 VGND VGND VPWR VPWR sky130_fd_sc_hd__decap_3
XFILLER_114_65 VGND VGND VPWR VPWR sky130_fd_sc_hd__decap_3
XFILLER_28_521 VGND VGND VPWR VPWR sky130_fd_sc_hd__fill_2
XFILLER_68_690 VGND VGND VPWR VPWR sky130_fd_sc_hd__fill_1
XFILLER_74_115 VGND VGND VPWR VPWR sky130_fd_sc_hd__decap_3
XFILLER_74_148 VGND VGND VPWR VPWR sky130_fd_sc_hd__decap_3
XFILLER_87_498 VGND VGND VPWR VPWR sky130_fd_sc_hd__decap_3
XFILLER_28_554 VGND VGND VPWR VPWR sky130_fd_sc_hd__decap_3
XFILLER_90_619 VGND VGND VPWR VPWR sky130_fd_sc_hd__decap_3
XFILLER_28_587 VGND VGND VPWR VPWR sky130_fd_sc_hd__fill_1
XFILLER_28_598 VGND VGND VPWR VPWR sky130_fd_sc_hd__decap_3
XFILLER_55_362 VGND VGND VPWR VPWR sky130_fd_sc_hd__decap_3
XFILLER_70_321 VGND VGND VPWR VPWR sky130_fd_sc_hd__decap_3
XFILLER_82_170 VGND VGND VPWR VPWR sky130_fd_sc_hd__decap_3
XFILLER_83_671 VGND VGND VPWR VPWR sky130_fd_sc_hd__fill_1
XFILLER_83_682 VGND VGND VPWR VPWR sky130_fd_sc_hd__decap_3
XTAP_TAPCELL_ROW_87_1296 VGND VPWR sky130_fd_sc_hd__tapvpwrvgnd_1
XFILLER_15_237 VGND VGND VPWR VPWR sky130_fd_sc_hd__decap_3
XFILLER_43_557 VGND VGND VPWR VPWR sky130_fd_sc_hd__decap_3
XFILLER_30_218 VGND VGND VPWR VPWR sky130_fd_sc_hd__decap_3
XFILLER_43_579 VGND VGND VPWR VPWR sky130_fd_sc_hd__decap_3
XFILLER_70_365 VGND VGND VPWR VPWR sky130_fd_sc_hd__decap_3
XTAP_TAPCELL_ROW_13_405 VGND VPWR sky130_fd_sc_hd__tapvpwrvgnd_1
XFILLER_23_270 VGND VGND VPWR VPWR sky130_fd_sc_hd__decap_3
XTAP_TAPCELL_ROW_41_747 VGND VPWR sky130_fd_sc_hd__tapvpwrvgnd_1
XPHY_EDGE_ROW_61_Right_61 VGND VGND VPWR VPWR sky130_fd_sc_hd__decap_3
XFILLER_11_443 VGND VGND VPWR VPWR sky130_fd_sc_hd__decap_3
XFILLER_7_403 VGND VGND VPWR VPWR sky130_fd_sc_hd__decap_3
XFILLER_7_447 VGND VGND VPWR VPWR sky130_fd_sc_hd__fill_1
XFILLER_3_620 VGND VGND VPWR VPWR sky130_fd_sc_hd__decap_3
XFILLER_112_507 VGND VGND VPWR VPWR sky130_fd_sc_hd__decap_3
XFILLER_2_130 VGND VGND VPWR VPWR sky130_fd_sc_hd__fill_1
XFILLER_3_653 VGND VGND VPWR VPWR sky130_fd_sc_hd__decap_3
XFILLER_105_570 VGND VGND VPWR VPWR sky130_fd_sc_hd__decap_3
XFILLER_2_141 VGND VGND VPWR VPWR sky130_fd_sc_hd__decap_3
XPHY_EDGE_ROW_70_Right_70 VGND VGND VPWR VPWR sky130_fd_sc_hd__decap_3
XFILLER_78_443 VGND VGND VPWR VPWR sky130_fd_sc_hd__decap_3
XFILLER_38_318 VGND VGND VPWR VPWR sky130_fd_sc_hd__decap_3
XFILLER_66_616 VGND VGND VPWR VPWR sky130_fd_sc_hd__decap_3
XFILLER_93_402 VGND VGND VPWR VPWR sky130_fd_sc_hd__decap_3
XFILLER_93_446 VGND VGND VPWR VPWR sky130_fd_sc_hd__fill_2
Xsingle_cycle_cpu_577 VGND VGND VPWR VPWR single_cycle_cpu_577/HI instruction_out[29]
+ sky130_fd_sc_hd__conb_1
XTAP_TAPCELL_ROW_49_836 VGND VPWR sky130_fd_sc_hd__tapvpwrvgnd_1
XFILLER_19_543 VGND VGND VPWR VPWR sky130_fd_sc_hd__decap_3
XFILLER_65_148 VGND VGND VPWR VPWR sky130_fd_sc_hd__decap_3
XFILLER_74_660 VGND VGND VPWR VPWR sky130_fd_sc_hd__decap_3
XFILLER_19_576 VGND VGND VPWR VPWR sky130_fd_sc_hd__decap_3
XFILLER_46_373 VGND VGND VPWR VPWR sky130_fd_sc_hd__fill_2
XFILLER_34_546 VGND VGND VPWR VPWR sky130_fd_sc_hd__fill_1
XFILLER_34_568 VGND VGND VPWR VPWR sky130_fd_sc_hd__decap_3
XPHY_EDGE_ROW_14_Left_131 VGND VGND VPWR VPWR sky130_fd_sc_hd__decap_3
X_4730_ _7007_/Q _4738_/A VGND VGND VPWR VPWR _4731_/A sky130_fd_sc_hd__or2_2
X_7380_ clkload8/A _7380_/D _6660_/Y VGND VGND VPWR VPWR _7380_/Q sky130_fd_sc_hd__dfrtp_2
X_6400_ _6632_/A VGND VGND VPWR VPWR _6400_/Y sky130_fd_sc_hd__inv_2
X_3612_ _3536_/B _4614_/B _3610_/Y _3611_/Y VGND VGND VPWR VPWR _3612_/X sky130_fd_sc_hd__a211o_2
Xhold904 _6979_/Q VGND VGND VPWR VPWR _5667_/A sky130_fd_sc_hd__dlygate4sd3_1
X_6331_ _6654_/A VGND VGND VPWR VPWR _6331_/Y sky130_fd_sc_hd__inv_2
XFILLER_6_480 VGND VGND VPWR VPWR sky130_fd_sc_hd__decap_3
Xhold915 _6705_/Q VGND VGND VPWR VPWR hold915/X sky130_fd_sc_hd__dlygate4sd3_1
Xhold926 _6688_/Q VGND VGND VPWR VPWR hold926/X sky130_fd_sc_hd__dlygate4sd3_1
Xhold937 _7036_/Q VGND VGND VPWR VPWR hold937/X sky130_fd_sc_hd__dlygate4sd3_1
X_3543_ _3540_/X _3541_/X _5144_/A VGND VGND VPWR VPWR _3630_/B sky130_fd_sc_hd__o21ai_2
XFILLER_115_345 VGND VGND VPWR VPWR sky130_fd_sc_hd__decap_3
XFILLER_115_356 VGND VGND VPWR VPWR sky130_fd_sc_hd__decap_3
Xhold959 _7011_/Q VGND VGND VPWR VPWR _5634_/A sky130_fd_sc_hd__dlygate4sd3_1
Xhold948 _7315_/Q VGND VGND VPWR VPWR _4528_/A sky130_fd_sc_hd__dlygate4sd3_1
X_6262_ _6629_/A VGND VGND VPWR VPWR _6262_/Y sky130_fd_sc_hd__inv_2
X_3474_ _7280_/Q _4534_/S _4318_/B1 _7152_/Q _3473_/X VGND VGND VPWR VPWR _3474_/X
+ sky130_fd_sc_hd__a221o_2
XPHY_EDGE_ROW_23_Left_140 VGND VGND VPWR VPWR sky130_fd_sc_hd__decap_3
XFILLER_103_529 VGND VGND VPWR VPWR sky130_fd_sc_hd__decap_3
XFILLER_115_389 VGND VGND VPWR VPWR sky130_fd_sc_hd__decap_3
XFILLER_88_229 VGND VGND VPWR VPWR sky130_fd_sc_hd__decap_3
X_5213_ _5213_/A _5225_/B VGND VGND VPWR VPWR _7222_/D sky130_fd_sc_hd__and2_2
X_5144_ _5144_/A _5144_/B VGND VGND VPWR VPWR _5145_/A sky130_fd_sc_hd__nand2_2
XFILLER_111_573 VGND VGND VPWR VPWR sky130_fd_sc_hd__decap_3
XFILLER_28_29 VGND VGND VPWR VPWR sky130_fd_sc_hd__decap_3
XFILLER_56_137 VGND VGND VPWR VPWR sky130_fd_sc_hd__decap_3
XFILLER_57_638 VGND VGND VPWR VPWR sky130_fd_sc_hd__decap_3
X_5075_ _5075_/A _5075_/B _5075_/C VGND VGND VPWR VPWR _5658_/A sky130_fd_sc_hd__or3_2
XFILLER_72_619 VGND VGND VPWR VPWR sky130_fd_sc_hd__decap_3
XFILLER_25_513 VGND VGND VPWR VPWR sky130_fd_sc_hd__decap_3
XFILLER_64_170 VGND VGND VPWR VPWR sky130_fd_sc_hd__decap_3
XFILLER_65_671 VGND VGND VPWR VPWR sky130_fd_sc_hd__fill_1
XFILLER_65_682 VGND VGND VPWR VPWR sky130_fd_sc_hd__decap_3
XFILLER_25_557 VGND VGND VPWR VPWR sky130_fd_sc_hd__decap_3
XFILLER_52_321 VGND VGND VPWR VPWR sky130_fd_sc_hd__fill_1
XFILLER_52_332 VGND VGND VPWR VPWR sky130_fd_sc_hd__decap_3
XFILLER_100_12 VGND VGND VPWR VPWR sky130_fd_sc_hd__decap_3
XFILLER_25_579 VGND VGND VPWR VPWR sky130_fd_sc_hd__decap_3
XFILLER_52_365 VGND VGND VPWR VPWR sky130_fd_sc_hd__decap_3
XFILLER_80_663 VGND VGND VPWR VPWR sky130_fd_sc_hd__decap_3
X_4928_ _6996_/Q _4928_/B _4943_/A VGND VGND VPWR VPWR _4928_/Y sky130_fd_sc_hd__nor3_2
X_4859_ _7000_/Q _4870_/A VGND VGND VPWR VPWR _4859_/Y sky130_fd_sc_hd__nor2_2
XFILLER_109_32 VGND VGND VPWR VPWR sky130_fd_sc_hd__decap_3
XFILLER_114_6 VGND VGND VPWR VPWR sky130_fd_sc_hd__decap_3
XFILLER_4_406 VGND VGND VPWR VPWR sky130_fd_sc_hd__fill_1
Xclkbuf_3_0__f_clk clkbuf_0_clk/X VGND VGND VPWR VPWR clkbuf_leaf_1_clk/A sky130_fd_sc_hd__clkbuf_16
X_6529_ _6603_/A VGND VGND VPWR VPWR _6529_/Y sky130_fd_sc_hd__inv_2
XFILLER_106_345 VGND VGND VPWR VPWR sky130_fd_sc_hd__decap_3
XFILLER_0_612 VGND VGND VPWR VPWR sky130_fd_sc_hd__decap_3
XFILLER_106_389 VGND VGND VPWR VPWR sky130_fd_sc_hd__decap_3
XFILLER_79_218 VGND VGND VPWR VPWR sky130_fd_sc_hd__decap_3
XFILLER_0_634 VGND VGND VPWR VPWR sky130_fd_sc_hd__decap_3
XFILLER_102_551 VGND VGND VPWR VPWR sky130_fd_sc_hd__decap_3
XFILLER_48_616 VGND VGND VPWR VPWR sky130_fd_sc_hd__decap_3
XFILLER_75_413 VGND VGND VPWR VPWR sky130_fd_sc_hd__fill_2
XFILLER_87_240 VGND VGND VPWR VPWR sky130_fd_sc_hd__decap_3
XFILLER_102_584 VGND VGND VPWR VPWR sky130_fd_sc_hd__decap_3
XFILLER_102_595 VGND VGND VPWR VPWR sky130_fd_sc_hd__decap_3
XFILLER_75_424 VGND VGND VPWR VPWR sky130_fd_sc_hd__decap_3
XFILLER_85_46 VGND VGND VPWR VPWR sky130_fd_sc_hd__fill_2
XFILLER_85_68 VGND VGND VPWR VPWR sky130_fd_sc_hd__fill_1
XTAP_TAPCELL_ROW_89_1325 VGND VPWR sky130_fd_sc_hd__tapvpwrvgnd_1
XTAP_TAPCELL_ROW_89_1314 VGND VPWR sky130_fd_sc_hd__tapvpwrvgnd_1
XFILLER_56_660 VGND VGND VPWR VPWR sky130_fd_sc_hd__decap_3
XTAP_TAPCELL_ROW_46_806 VGND VPWR sky130_fd_sc_hd__tapvpwrvgnd_1
XFILLER_62_118 VGND VGND VPWR VPWR sky130_fd_sc_hd__fill_1
XFILLER_16_557 VGND VGND VPWR VPWR sky130_fd_sc_hd__decap_3
XFILLER_43_332 VGND VGND VPWR VPWR sky130_fd_sc_hd__decap_3
XFILLER_43_343 VGND VGND VPWR VPWR sky130_fd_sc_hd__decap_3
XFILLER_71_641 VGND VGND VPWR VPWR sky130_fd_sc_hd__decap_3
XFILLER_31_505 VGND VGND VPWR VPWR sky130_fd_sc_hd__decap_3
XFILLER_70_151 VGND VGND VPWR VPWR sky130_fd_sc_hd__decap_3
XFILLER_71_685 VGND VGND VPWR VPWR sky130_fd_sc_hd__decap_3
XTAP_TAPCELL_ROW_26_563 VGND VPWR sky130_fd_sc_hd__tapvpwrvgnd_1
XTAP_TAPCELL_ROW_54_894 VGND VPWR sky130_fd_sc_hd__tapvpwrvgnd_1
XFILLER_11_262 VGND VGND VPWR VPWR sky130_fd_sc_hd__decap_3
XFILLER_7_222 VGND VGND VPWR VPWR sky130_fd_sc_hd__fill_2
XFILLER_116_109 VGND VGND VPWR VPWR sky130_fd_sc_hd__decap_3
XFILLER_50_82 VGND VGND VPWR VPWR sky130_fd_sc_hd__fill_2
XFILLER_7_277 VGND VGND VPWR VPWR sky130_fd_sc_hd__decap_3
XFILLER_112_315 VGND VGND VPWR VPWR sky130_fd_sc_hd__decap_3
XFILLER_3_472 VGND VGND VPWR VPWR sky130_fd_sc_hd__decap_3
XFILLER_98_516 VGND VGND VPWR VPWR sky130_fd_sc_hd__decap_3
XFILLER_78_240 VGND VGND VPWR VPWR sky130_fd_sc_hd__fill_2
XFILLER_78_251 VGND VGND VPWR VPWR sky130_fd_sc_hd__fill_1
XFILLER_78_262 VGND VGND VPWR VPWR sky130_fd_sc_hd__decap_3
XFILLER_39_638 VGND VGND VPWR VPWR sky130_fd_sc_hd__decap_3
XFILLER_66_424 VGND VGND VPWR VPWR sky130_fd_sc_hd__decap_3
XFILLER_19_340 VGND VGND VPWR VPWR sky130_fd_sc_hd__fill_2
XFILLER_54_619 VGND VGND VPWR VPWR sky130_fd_sc_hd__decap_3
XFILLER_93_265 VGND VGND VPWR VPWR sky130_fd_sc_hd__decap_3
XFILLER_19_351 VGND VGND VPWR VPWR sky130_fd_sc_hd__decap_3
XFILLER_19_362 VGND VGND VPWR VPWR sky130_fd_sc_hd__decap_3
XFILLER_47_671 VGND VGND VPWR VPWR sky130_fd_sc_hd__fill_1
XFILLER_47_682 VGND VGND VPWR VPWR sky130_fd_sc_hd__decap_3
XFILLER_93_276 VGND VGND VPWR VPWR sky130_fd_sc_hd__decap_3
XTAP_TAPCELL_ROW_109_1561 VGND VPWR sky130_fd_sc_hd__tapvpwrvgnd_1
X_6880_ _6943_/CLK _6880_/D VGND VGND VPWR VPWR _6880_/Q sky130_fd_sc_hd__dfxtp_2
XFILLER_34_354 VGND VGND VPWR VPWR sky130_fd_sc_hd__decap_3
XFILLER_62_663 VGND VGND VPWR VPWR sky130_fd_sc_hd__decap_3
X_4713_ _7008_/Q _4731_/B VGND VGND VPWR VPWR _7008_/D sky130_fd_sc_hd__xnor2_2
XFILLER_30_582 VGND VGND VPWR VPWR sky130_fd_sc_hd__decap_3
X_5693_ _7352_/Q hold907/X _5708_/S VGND VGND VPWR VPWR _6696_/D sky130_fd_sc_hd__mux2_2
X_4644_ _4111_/B _4643_/Y _4633_/A _4109_/X VGND VGND VPWR VPWR _4644_/X sky130_fd_sc_hd__a211o_2
X_7363_ _7368_/CLK _7363_/D _6643_/Y VGND VGND VPWR VPWR _7363_/Q sky130_fd_sc_hd__dfrtp_2
Xhold701 _6917_/Q VGND VGND VPWR VPWR _6917_/D sky130_fd_sc_hd__dlygate4sd3_1
Xhold712 _6772_/Q VGND VGND VPWR VPWR _6772_/D sky130_fd_sc_hd__dlygate4sd3_1
X_4575_ _4575_/A _4595_/B VGND VGND VPWR VPWR _7293_/D sky130_fd_sc_hd__and2_2
XFILLER_115_131 VGND VGND VPWR VPWR sky130_fd_sc_hd__decap_3
XFILLER_116_643 VGND VGND VPWR VPWR sky130_fd_sc_hd__fill_1
XFILLER_89_505 VGND VGND VPWR VPWR sky130_fd_sc_hd__decap_3
X_7294_ _7322_/CLK _7294_/D _6574_/Y VGND VGND VPWR VPWR _7294_/Q sky130_fd_sc_hd__dfrtp_2
Xhold723 _6725_/Q VGND VGND VPWR VPWR _6725_/D sky130_fd_sc_hd__dlygate4sd3_1
Xhold734 _6847_/Q VGND VGND VPWR VPWR _6847_/D sky130_fd_sc_hd__dlygate4sd3_1
Xhold745 _6872_/Q VGND VGND VPWR VPWR _6872_/D sky130_fd_sc_hd__dlygate4sd3_1
X_6314_ _6632_/A VGND VGND VPWR VPWR _6314_/Y sky130_fd_sc_hd__inv_2
X_3526_ _4938_/A _3609_/B VGND VGND VPWR VPWR _5057_/A sky130_fd_sc_hd__nand2_2
XFILLER_115_175 VGND VGND VPWR VPWR sky130_fd_sc_hd__decap_3
XFILLER_116_676 VGND VGND VPWR VPWR sky130_fd_sc_hd__decap_3
XFILLER_89_516 VGND VGND VPWR VPWR sky130_fd_sc_hd__fill_1
XFILLER_89_538 VGND VGND VPWR VPWR sky130_fd_sc_hd__decap_3
Xhold756 _6740_/Q VGND VGND VPWR VPWR _6740_/D sky130_fd_sc_hd__dlygate4sd3_1
Xhold767 _6823_/Q VGND VGND VPWR VPWR _6823_/D sky130_fd_sc_hd__dlygate4sd3_1
Xhold778 _6780_/Q VGND VGND VPWR VPWR _6780_/D sky130_fd_sc_hd__dlygate4sd3_1
XTAP_TAPCELL_ROW_73_1126 VGND VPWR sky130_fd_sc_hd__tapvpwrvgnd_1
XFILLER_103_337 VGND VGND VPWR VPWR sky130_fd_sc_hd__decap_3
Xhold789 _6977_/Q VGND VGND VPWR VPWR _6977_/D sky130_fd_sc_hd__dlygate4sd3_1
X_3457_ _4394_/A _3449_/C _3424_/S _3456_/X VGND VGND VPWR VPWR _3506_/B sky130_fd_sc_hd__a22o_2
XFILLER_69_251 VGND VGND VPWR VPWR sky130_fd_sc_hd__decap_3
X_3388_ _3394_/A _3429_/B VGND VGND VPWR VPWR _3556_/A sky130_fd_sc_hd__nor2_2
XFILLER_69_284 VGND VGND VPWR VPWR sky130_fd_sc_hd__fill_1
XFILLER_84_210 VGND VGND VPWR VPWR sky130_fd_sc_hd__fill_1
XFILLER_97_582 VGND VGND VPWR VPWR sky130_fd_sc_hd__decap_3
XFILLER_57_468 VGND VGND VPWR VPWR sky130_fd_sc_hd__decap_3
XFILLER_57_479 VGND VGND VPWR VPWR sky130_fd_sc_hd__decap_3
X_5058_ _5114_/A _4330_/B _5056_/X _5057_/Y VGND VGND VPWR VPWR _5662_/B sky130_fd_sc_hd__a211o_2
XPHY_EDGE_ROW_2_Right_2 VGND VGND VPWR VPWR sky130_fd_sc_hd__decap_3
XFILLER_38_660 VGND VGND VPWR VPWR sky130_fd_sc_hd__decap_3
XFILLER_44_118 VGND VGND VPWR VPWR sky130_fd_sc_hd__decap_3
XFILLER_84_265 VGND VGND VPWR VPWR sky130_fd_sc_hd__decap_3
XFILLER_37_192 VGND VGND VPWR VPWR sky130_fd_sc_hd__fill_2
XFILLER_53_641 VGND VGND VPWR VPWR sky130_fd_sc_hd__decap_3
XFILLER_111_33 VGND VGND VPWR VPWR sky130_fd_sc_hd__decap_3
XFILLER_53_685 VGND VGND VPWR VPWR sky130_fd_sc_hd__decap_3
XTAP_TAPCELL_ROW_84_1255 VGND VPWR sky130_fd_sc_hd__tapvpwrvgnd_1
XFILLER_111_66 VGND VGND VPWR VPWR sky130_fd_sc_hd__decap_3
XFILLER_13_549 VGND VGND VPWR VPWR sky130_fd_sc_hd__decap_3
XTAP_TAPCELL_ROW_23_522 VGND VPWR sky130_fd_sc_hd__tapvpwrvgnd_1
XTAP_TAPCELL_ROW_51_864 VGND VPWR sky130_fd_sc_hd__tapvpwrvgnd_1
XTAP_TAPCELL_ROW_23_533 VGND VPWR sky130_fd_sc_hd__tapvpwrvgnd_1
XFILLER_21_582 VGND VGND VPWR VPWR sky130_fd_sc_hd__decap_3
XFILLER_107_632 VGND VGND VPWR VPWR sky130_fd_sc_hd__decap_3
XFILLER_112_3 VGND VGND VPWR VPWR sky130_fd_sc_hd__decap_3
XFILLER_106_131 VGND VGND VPWR VPWR sky130_fd_sc_hd__decap_3
XFILLER_107_665 VGND VGND VPWR VPWR sky130_fd_sc_hd__decap_3
XFILLER_4_247 VGND VGND VPWR VPWR sky130_fd_sc_hd__decap_3
XFILLER_4_258 VGND VGND VPWR VPWR sky130_fd_sc_hd__decap_3
XFILLER_107_676 VGND VGND VPWR VPWR sky130_fd_sc_hd__decap_3
XFILLER_20_85 VGND VGND VPWR VPWR sky130_fd_sc_hd__decap_3
XTAP_TAPCELL_ROW_95_1395 VGND VPWR sky130_fd_sc_hd__tapvpwrvgnd_1
XFILLER_96_12 VGND VGND VPWR VPWR sky130_fd_sc_hd__decap_3
XFILLER_88_560 VGND VGND VPWR VPWR sky130_fd_sc_hd__decap_3
XFILLER_95_508 VGND VGND VPWR VPWR sky130_fd_sc_hd__decap_3
XFILLER_0_486 VGND VGND VPWR VPWR sky130_fd_sc_hd__decap_3
XFILLER_102_392 VGND VGND VPWR VPWR sky130_fd_sc_hd__decap_3
XFILLER_36_619 VGND VGND VPWR VPWR sky130_fd_sc_hd__decap_3
XFILLER_48_446 VGND VGND VPWR VPWR sky130_fd_sc_hd__decap_3
XTAP_TAPCELL_ROW_59_964 VGND VPWR sky130_fd_sc_hd__tapvpwrvgnd_1
XFILLER_29_671 VGND VGND VPWR VPWR sky130_fd_sc_hd__fill_1
XFILLER_29_682 VGND VGND VPWR VPWR sky130_fd_sc_hd__decap_3
XFILLER_35_107 VGND VGND VPWR VPWR sky130_fd_sc_hd__decap_3
XFILLER_75_287 VGND VGND VPWR VPWR sky130_fd_sc_hd__decap_3
XFILLER_28_192 VGND VGND VPWR VPWR sky130_fd_sc_hd__decap_3
Xplace405 _4269_/B1 VGND VGND VPWR VPWR _4478_/S sky130_fd_sc_hd__buf_2
Xplace416 _3376_/Y VGND VGND VPWR VPWR _5161_/A sky130_fd_sc_hd__buf_2
Xplace427 _4471_/S VGND VGND VPWR VPWR _3987_/S sky130_fd_sc_hd__buf_2
Xplace438 _4927_/A VGND VGND VPWR VPWR _4983_/A sky130_fd_sc_hd__buf_2
XTAP_TAPCELL_ROW_3_291 VGND VPWR sky130_fd_sc_hd__tapvpwrvgnd_1
XFILLER_16_365 VGND VGND VPWR VPWR sky130_fd_sc_hd__decap_3
XFILLER_44_663 VGND VGND VPWR VPWR sky130_fd_sc_hd__decap_3
Xplace449 _6983_/Q VGND VGND VPWR VPWR _3561_/B sky130_fd_sc_hd__buf_2
XFILLER_16_387 VGND VGND VPWR VPWR sky130_fd_sc_hd__decap_3
XFILLER_31_324 VGND VGND VPWR VPWR sky130_fd_sc_hd__decap_3
XFILLER_31_368 VGND VGND VPWR VPWR sky130_fd_sc_hd__decap_3
XFILLER_12_560 VGND VGND VPWR VPWR sky130_fd_sc_hd__decap_3
XFILLER_8_531 VGND VGND VPWR VPWR sky130_fd_sc_hd__fill_1
XFILLER_8_542 VGND VGND VPWR VPWR sky130_fd_sc_hd__decap_3
XANTENNA_3 _7348_/Q VGND VGND VPWR VPWR sky130_fd_sc_hd__diode_2
XFILLER_8_575 VGND VGND VPWR VPWR sky130_fd_sc_hd__decap_3
X_4360_ _5072_/B _5071_/B VGND VGND VPWR VPWR _5073_/A sky130_fd_sc_hd__nand2_2
X_3311_ _5118_/C _4696_/B _3340_/B VGND VGND VPWR VPWR _5671_/A sky130_fd_sc_hd__o21ai_2
XFILLER_113_635 VGND VGND VPWR VPWR sky130_fd_sc_hd__decap_3
X_4291_ _4612_/A _4612_/B VGND VGND VPWR VPWR _4292_/C sky130_fd_sc_hd__xnor2_2
XFILLER_113_668 VGND VGND VPWR VPWR sky130_fd_sc_hd__decap_3
XFILLER_113_679 VGND VGND VPWR VPWR sky130_fd_sc_hd__decap_3
XFILLER_100_318 VGND VGND VPWR VPWR sky130_fd_sc_hd__decap_3
XFILLER_39_435 VGND VGND VPWR VPWR sky130_fd_sc_hd__fill_1
XFILLER_79_582 VGND VGND VPWR VPWR sky130_fd_sc_hd__decap_3
XFILLER_39_468 VGND VGND VPWR VPWR sky130_fd_sc_hd__fill_1
XFILLER_94_563 VGND VGND VPWR VPWR sky130_fd_sc_hd__decap_3
XFILLER_54_405 VGND VGND VPWR VPWR sky130_fd_sc_hd__decap_3
XFILLER_54_416 VGND VGND VPWR VPWR sky130_fd_sc_hd__decap_3
XFILLER_66_265 VGND VGND VPWR VPWR sky130_fd_sc_hd__decap_3
XFILLER_66_287 VGND VGND VPWR VPWR sky130_fd_sc_hd__decap_3
XFILLER_81_202 VGND VGND VPWR VPWR sky130_fd_sc_hd__decap_3
XFILLER_19_192 VGND VGND VPWR VPWR sky130_fd_sc_hd__decap_3
XFILLER_35_641 VGND VGND VPWR VPWR sky130_fd_sc_hd__decap_3
XFILLER_81_246 VGND VGND VPWR VPWR sky130_fd_sc_hd__fill_2
X_6932_ _6965_/CLK _6932_/D VGND VGND VPWR VPWR _6932_/Q sky130_fd_sc_hd__dfxtp_2
XFILLER_62_460 VGND VGND VPWR VPWR sky130_fd_sc_hd__decap_3
X_6863_ _6968_/CLK _6863_/D VGND VGND VPWR VPWR _6863_/Q sky130_fd_sc_hd__dfxtp_2
XFILLER_35_685 VGND VGND VPWR VPWR sky130_fd_sc_hd__decap_3
XFILLER_50_622 VGND VGND VPWR VPWR sky130_fd_sc_hd__decap_3
XFILLER_22_368 VGND VGND VPWR VPWR sky130_fd_sc_hd__fill_1
XFILLER_34_195 VGND VGND VPWR VPWR sky130_fd_sc_hd__fill_1
XFILLER_50_666 VGND VGND VPWR VPWR sky130_fd_sc_hd__decap_3
X_6794_ clkload8/A _6794_/D VGND VGND VPWR VPWR _6794_/Q sky130_fd_sc_hd__dfxtp_2
X_5676_ _7344_/Q hold926/X _5708_/S VGND VGND VPWR VPWR _6688_/D sky130_fd_sc_hd__mux2_2
XFILLER_108_418 VGND VGND VPWR VPWR sky130_fd_sc_hd__fill_2
X_4627_ _4627_/A VGND VGND VPWR VPWR _4627_/Y sky130_fd_sc_hd__inv_2
XFILLER_104_613 VGND VGND VPWR VPWR sky130_fd_sc_hd__decap_3
X_7346_ _7351_/CLK _7346_/D _6626_/Y VGND VGND VPWR VPWR _7346_/Q sky130_fd_sc_hd__dfrtp_2
XFILLER_103_101 VGND VGND VPWR VPWR sky130_fd_sc_hd__fill_2
XFILLER_104_657 VGND VGND VPWR VPWR sky130_fd_sc_hd__decap_3
XFILLER_106_11 VGND VGND VPWR VPWR sky130_fd_sc_hd__decap_3
XFILLER_1_228 VGND VGND VPWR VPWR sky130_fd_sc_hd__decap_3
X_7277_ _7372_/CLK _7277_/D _6557_/Y VGND VGND VPWR VPWR _7277_/Q sky130_fd_sc_hd__dfrtp_2
Xhold586 _6932_/Q VGND VGND VPWR VPWR _6932_/D sky130_fd_sc_hd__dlygate4sd3_1
Xhold597 _6741_/Q VGND VGND VPWR VPWR _6741_/D sky130_fd_sc_hd__dlygate4sd3_1
X_3509_ _5640_/B _3509_/B VGND VGND VPWR VPWR _3509_/Y sky130_fd_sc_hd__nor2_2
XFILLER_103_145 VGND VGND VPWR VPWR sky130_fd_sc_hd__decap_3
XFILLER_106_44 VGND VGND VPWR VPWR sky130_fd_sc_hd__decap_3
XFILLER_89_368 VGND VGND VPWR VPWR sky130_fd_sc_hd__decap_3
XFILLER_103_178 VGND VGND VPWR VPWR sky130_fd_sc_hd__decap_3
XFILLER_112_690 VGND VGND VPWR VPWR sky130_fd_sc_hd__fill_1
XFILLER_66_15 VGND VGND VPWR VPWR sky130_fd_sc_hd__decap_3
XFILLER_106_99 VGND VGND VPWR VPWR sky130_fd_sc_hd__decap_3
XFILLER_57_243 VGND VGND VPWR VPWR sky130_fd_sc_hd__decap_3
XFILLER_85_530 VGND VGND VPWR VPWR sky130_fd_sc_hd__decap_3
Xhold1220 _7188_/Q VGND VGND VPWR VPWR _5283_/B2 sky130_fd_sc_hd__dlygate4sd3_1
XFILLER_17_107 VGND VGND VPWR VPWR sky130_fd_sc_hd__decap_3
XFILLER_18_619 VGND VGND VPWR VPWR sky130_fd_sc_hd__decap_3
XFILLER_45_416 VGND VGND VPWR VPWR sky130_fd_sc_hd__decap_3
XFILLER_85_585 VGND VGND VPWR VPWR sky130_fd_sc_hd__decap_3
XTAP_TAPCELL_ROW_56_923 VGND VPWR sky130_fd_sc_hd__tapvpwrvgnd_1
Xclkbuf_leaf_37_clk clkload1/A VGND VGND VPWR VPWR _7383_/CLK sky130_fd_sc_hd__clkbuf_16
XFILLER_26_663 VGND VGND VPWR VPWR sky130_fd_sc_hd__decap_3
XFILLER_41_600 VGND VGND VPWR VPWR sky130_fd_sc_hd__decap_3
XFILLER_60_419 VGND VGND VPWR VPWR sky130_fd_sc_hd__fill_1
XFILLER_72_268 VGND VGND VPWR VPWR sky130_fd_sc_hd__decap_3
XTAP_TAPCELL_ROW_0_250 VGND VPWR sky130_fd_sc_hd__tapvpwrvgnd_1
XFILLER_25_162 VGND VGND VPWR VPWR sky130_fd_sc_hd__decap_3
XFILLER_53_482 VGND VGND VPWR VPWR sky130_fd_sc_hd__fill_1
XTAP_TAPCELL_ROW_36_680 VGND VPWR sky130_fd_sc_hd__tapvpwrvgnd_1
XFILLER_41_644 VGND VGND VPWR VPWR sky130_fd_sc_hd__decap_3
XFILLER_41_688 VGND VGND VPWR VPWR sky130_fd_sc_hd__decap_3
XTAP_TAPCELL_ROW_97_1413 VGND VPWR sky130_fd_sc_hd__tapvpwrvgnd_1
XFILLER_5_523 VGND VGND VPWR VPWR sky130_fd_sc_hd__decap_3
XFILLER_5_556 VGND VGND VPWR VPWR sky130_fd_sc_hd__decap_3
XFILLER_107_473 VGND VGND VPWR VPWR sky130_fd_sc_hd__decap_3
XFILLER_5_567 VGND VGND VPWR VPWR sky130_fd_sc_hd__decap_3
XFILLER_110_616 VGND VGND VPWR VPWR sky130_fd_sc_hd__decap_3
XTAP_TAPCELL_ROW_8_350 VGND VPWR sky130_fd_sc_hd__tapvpwrvgnd_1
XFILLER_0_250 VGND VGND VPWR VPWR sky130_fd_sc_hd__fill_2
XFILLER_0_261 VGND VGND VPWR VPWR sky130_fd_sc_hd__decap_3
XFILLER_76_530 VGND VGND VPWR VPWR sky130_fd_sc_hd__fill_2
XFILLER_36_416 VGND VGND VPWR VPWR sky130_fd_sc_hd__decap_3
XFILLER_48_265 VGND VGND VPWR VPWR sky130_fd_sc_hd__decap_3
XFILLER_48_287 VGND VGND VPWR VPWR sky130_fd_sc_hd__decap_3
XFILLER_76_563 VGND VGND VPWR VPWR sky130_fd_sc_hd__decap_3
XFILLER_91_511 VGND VGND VPWR VPWR sky130_fd_sc_hd__decap_3
XFILLER_17_641 VGND VGND VPWR VPWR sky130_fd_sc_hd__decap_3
XFILLER_56_81 VGND VGND VPWR VPWR sky130_fd_sc_hd__decap_3
XFILLER_63_213 VGND VGND VPWR VPWR sky130_fd_sc_hd__decap_3
XFILLER_63_246 VGND VGND VPWR VPWR sky130_fd_sc_hd__decap_3
XFILLER_91_555 VGND VGND VPWR VPWR sky130_fd_sc_hd__decap_3
Xclkbuf_leaf_28_clk clkload2/A VGND VGND VPWR VPWR _7353_/CLK sky130_fd_sc_hd__clkbuf_16
XTAP_TAPCELL_ROW_106_1520 VGND VPWR sky130_fd_sc_hd__tapvpwrvgnd_1
XFILLER_91_588 VGND VGND VPWR VPWR sky130_fd_sc_hd__decap_3
XFILLER_16_184 VGND VGND VPWR VPWR sky130_fd_sc_hd__decap_3
XFILLER_17_685 VGND VGND VPWR VPWR sky130_fd_sc_hd__decap_3
XFILLER_31_110 VGND VGND VPWR VPWR sky130_fd_sc_hd__fill_2
XFILLER_32_622 VGND VGND VPWR VPWR sky130_fd_sc_hd__decap_3
Xplace279 _3661_/X VGND VGND VPWR VPWR _3886_/A2 sky130_fd_sc_hd__buf_2
Xplace268 _5116_/Y VGND VGND VPWR VPWR _5658_/D sky130_fd_sc_hd__buf_2
XFILLER_16_195 VGND VGND VPWR VPWR sky130_fd_sc_hd__fill_1
XFILLER_32_666 VGND VGND VPWR VPWR sky130_fd_sc_hd__decap_3
XFILLER_71_290 VGND VGND VPWR VPWR sky130_fd_sc_hd__decap_3
XFILLER_72_80 VGND VGND VPWR VPWR sky130_fd_sc_hd__decap_3
X_3860_ _3860_/A0 _3859_/X _3904_/A VGND VGND VPWR VPWR _7386_/D sky130_fd_sc_hd__mux2_2
XFILLER_31_165 VGND VGND VPWR VPWR sky130_fd_sc_hd__decap_3
X_3791_ _3775_/X _3790_/X _3904_/A VGND VGND VPWR VPWR _4961_/A sky130_fd_sc_hd__o21a_2
XFILLER_12_390 VGND VGND VPWR VPWR sky130_fd_sc_hd__decap_3
XFILLER_75_3 VGND VGND VPWR VPWR sky130_fd_sc_hd__decap_3
X_7200_ _7362_/CLK _7200_/D _6480_/Y VGND VGND VPWR VPWR _7200_/Q sky130_fd_sc_hd__dfrtp_2
X_4412_ _4788_/B _4412_/B VGND VGND VPWR VPWR _4413_/A sky130_fd_sc_hd__or2_2
X_5392_ _5392_/A0 _4945_/X _5409_/S VGND VGND VPWR VPWR _7137_/D sky130_fd_sc_hd__mux2_2
XFILLER_99_600 VGND VGND VPWR VPWR sky130_fd_sc_hd__decap_3
XFILLER_113_432 VGND VGND VPWR VPWR sky130_fd_sc_hd__decap_3
X_7131_ _7322_/CLK _7131_/D _6411_/Y VGND VGND VPWR VPWR _7131_/Q sky130_fd_sc_hd__dfrtp_2
X_4343_ _4365_/C _4365_/A _4365_/B VGND VGND VPWR VPWR _4343_/X sky130_fd_sc_hd__and3b_2
XPHY_EDGE_ROW_99_Right_99 VGND VGND VPWR VPWR sky130_fd_sc_hd__decap_3
XFILLER_99_644 VGND VGND VPWR VPWR sky130_fd_sc_hd__decap_3
XFILLER_59_508 VGND VGND VPWR VPWR sky130_fd_sc_hd__decap_3
X_7062_ _7311_/CLK _7062_/D _6342_/Y VGND VGND VPWR VPWR _7062_/Q sky130_fd_sc_hd__dfrtp_2
X_4274_ _4376_/A _4376_/B _4376_/C _4273_/D VGND VGND VPWR VPWR _4274_/Y sky130_fd_sc_hd__o31ai_2
XFILLER_99_688 VGND VGND VPWR VPWR sky130_fd_sc_hd__decap_3
XFILLER_101_638 VGND VGND VPWR VPWR sky130_fd_sc_hd__decap_3
XFILLER_113_476 VGND VGND VPWR VPWR sky130_fd_sc_hd__decap_3
XFILLER_86_338 VGND VGND VPWR VPWR sky130_fd_sc_hd__decap_3
XFILLER_100_126 VGND VGND VPWR VPWR sky130_fd_sc_hd__decap_3
XFILLER_79_390 VGND VGND VPWR VPWR sky130_fd_sc_hd__fill_2
XFILLER_39_254 VGND VGND VPWR VPWR sky130_fd_sc_hd__decap_3
XFILLER_67_585 VGND VGND VPWR VPWR sky130_fd_sc_hd__decap_3
XFILLER_27_427 VGND VGND VPWR VPWR sky130_fd_sc_hd__decap_3
XFILLER_36_29 VGND VGND VPWR VPWR sky130_fd_sc_hd__fill_2
XFILLER_82_533 VGND VGND VPWR VPWR sky130_fd_sc_hd__decap_3
XFILLER_94_382 VGND VGND VPWR VPWR sky130_fd_sc_hd__decap_3
Xclkbuf_leaf_19_clk clkload5/A VGND VGND VPWR VPWR _7395_/CLK sky130_fd_sc_hd__clkbuf_16
XPHY_EDGE_ROW_6_Left_123 VGND VGND VPWR VPWR sky130_fd_sc_hd__decap_3
XFILLER_42_408 VGND VGND VPWR VPWR sky130_fd_sc_hd__decap_3
XFILLER_82_566 VGND VGND VPWR VPWR sky130_fd_sc_hd__decap_3
X_6915_ _6943_/CLK _6915_/D VGND VGND VPWR VPWR _6915_/Q sky130_fd_sc_hd__dfxtp_2
XTAP_TAPCELL_ROW_68_1069 VGND VPWR sky130_fd_sc_hd__tapvpwrvgnd_1
XFILLER_23_600 VGND VGND VPWR VPWR sky130_fd_sc_hd__decap_3
XTAP_TAPCELL_ROW_81_1225 VGND VPWR sky130_fd_sc_hd__tapvpwrvgnd_1
XFILLER_23_644 VGND VGND VPWR VPWR sky130_fd_sc_hd__decap_3
XFILLER_50_430 VGND VGND VPWR VPWR sky130_fd_sc_hd__decap_3
XFILLER_62_290 VGND VGND VPWR VPWR sky130_fd_sc_hd__fill_1
X_6846_ _6954_/CLK _6846_/D VGND VGND VPWR VPWR _6846_/Q sky130_fd_sc_hd__dfxtp_2
XFILLER_23_688 VGND VGND VPWR VPWR sky130_fd_sc_hd__decap_3
X_6777_ _6943_/CLK _6777_/D VGND VGND VPWR VPWR _6777_/Q sky130_fd_sc_hd__dfxtp_2
XTAP_TAPCELL_ROW_61_981 VGND VPWR sky130_fd_sc_hd__tapvpwrvgnd_1
XTAP_TAPCELL_ROW_33_650 VGND VPWR sky130_fd_sc_hd__tapvpwrvgnd_1
XFILLER_10_327 VGND VGND VPWR VPWR sky130_fd_sc_hd__fill_1
X_3989_ _7346_/Q _4530_/A0 _3989_/S VGND VGND VPWR VPWR _7346_/D sky130_fd_sc_hd__mux2_2
XFILLER_108_215 VGND VGND VPWR VPWR sky130_fd_sc_hd__decap_3
XFILLER_6_309 VGND VGND VPWR VPWR sky130_fd_sc_hd__decap_3
X_5659_ _5659_/A _5659_/B VGND VGND VPWR VPWR _5660_/D sky130_fd_sc_hd__nor2_2
XFILLER_2_504 VGND VGND VPWR VPWR sky130_fd_sc_hd__decap_3
XTAP_TAPCELL_ROW_79_1198 VGND VPWR sky130_fd_sc_hd__tapvpwrvgnd_1
XFILLER_116_281 VGND VGND VPWR VPWR sky130_fd_sc_hd__decap_3
XFILLER_2_548 VGND VGND VPWR VPWR sky130_fd_sc_hd__decap_3
X_7329_ _7332_/CLK _7329_/D _6609_/Y VGND VGND VPWR VPWR _7329_/Q sky130_fd_sc_hd__dfrtp_2
XTAP_TAPCELL_ROW_92_1354 VGND VPWR sky130_fd_sc_hd__tapvpwrvgnd_1
XFILLER_104_498 VGND VGND VPWR VPWR sky130_fd_sc_hd__decap_3
XFILLER_77_327 VGND VGND VPWR VPWR sky130_fd_sc_hd__decap_3
XFILLER_89_187 VGND VGND VPWR VPWR sky130_fd_sc_hd__fill_1
XFILLER_89_198 VGND VGND VPWR VPWR sky130_fd_sc_hd__decap_3
XFILLER_100_660 VGND VGND VPWR VPWR sky130_fd_sc_hd__decap_3
XFILLER_45_202 VGND VGND VPWR VPWR sky130_fd_sc_hd__decap_3
XFILLER_58_574 VGND VGND VPWR VPWR sky130_fd_sc_hd__decap_3
XFILLER_85_360 VGND VGND VPWR VPWR sky130_fd_sc_hd__decap_3
XFILLER_85_371 VGND VGND VPWR VPWR sky130_fd_sc_hd__decap_3
XFILLER_93_24 VGND VGND VPWR VPWR sky130_fd_sc_hd__fill_1
Xhold1050 _7195_/Q VGND VGND VPWR VPWR _5270_/A0 sky130_fd_sc_hd__dlygate4sd3_1
XFILLER_85_393 VGND VGND VPWR VPWR sky130_fd_sc_hd__decap_3
XFILLER_93_57 VGND VGND VPWR VPWR sky130_fd_sc_hd__fill_2
Xhold1061 _7277_/Q VGND VGND VPWR VPWR _4735_/A0 sky130_fd_sc_hd__dlygate4sd3_1
Xhold1072 _7015_/Q VGND VGND VPWR VPWR _5626_/A sky130_fd_sc_hd__dlygate4sd3_1
Xhold1083 _7264_/Q VGND VGND VPWR VPWR _4965_/A0 sky130_fd_sc_hd__dlygate4sd3_1
Xhold1094 _7337_/Q VGND VGND VPWR VPWR _4484_/A0 sky130_fd_sc_hd__dlygate4sd3_1
XFILLER_45_246 VGND VGND VPWR VPWR sky130_fd_sc_hd__decap_3
XFILLER_14_622 VGND VGND VPWR VPWR sky130_fd_sc_hd__decap_3
XFILLER_26_460 VGND VGND VPWR VPWR sky130_fd_sc_hd__decap_3
XFILLER_73_588 VGND VGND VPWR VPWR sky130_fd_sc_hd__decap_3
XFILLER_14_666 VGND VGND VPWR VPWR sky130_fd_sc_hd__decap_3
XFILLER_53_290 VGND VGND VPWR VPWR sky130_fd_sc_hd__decap_3
XFILLER_13_143 VGND VGND VPWR VPWR sky130_fd_sc_hd__fill_2
XTAP_TAPCELL_ROW_101_1461 VGND VPWR sky130_fd_sc_hd__tapvpwrvgnd_1
XFILLER_42_94 VGND VGND VPWR VPWR sky130_fd_sc_hd__fill_1
XFILLER_9_169 VGND VGND VPWR VPWR sky130_fd_sc_hd__fill_2
XFILLER_61_9 VGND VGND VPWR VPWR sky130_fd_sc_hd__decap_3
XTAP_TAPCELL_ROW_11_388 VGND VPWR sky130_fd_sc_hd__tapvpwrvgnd_1
XFILLER_107_270 VGND VGND VPWR VPWR sky130_fd_sc_hd__fill_2
XFILLER_107_281 VGND VGND VPWR VPWR sky130_fd_sc_hd__decap_3
XFILLER_110_424 VGND VGND VPWR VPWR sky130_fd_sc_hd__decap_3
XFILLER_1_570 VGND VGND VPWR VPWR sky130_fd_sc_hd__fill_1
XFILLER_95_102 VGND VGND VPWR VPWR sky130_fd_sc_hd__fill_1
XFILLER_95_113 VGND VGND VPWR VPWR sky130_fd_sc_hd__fill_2
XFILLER_96_625 VGND VGND VPWR VPWR sky130_fd_sc_hd__decap_3
XFILLER_110_457 VGND VGND VPWR VPWR sky130_fd_sc_hd__decap_3
XFILLER_1_592 VGND VGND VPWR VPWR sky130_fd_sc_hd__decap_3
XFILLER_96_669 VGND VGND VPWR VPWR sky130_fd_sc_hd__decap_3
XTAP_TAPCELL_ROW_112_1590 VGND VPWR sky130_fd_sc_hd__tapvpwrvgnd_1
XPHY_EDGE_ROW_79_Left_196 VGND VGND VPWR VPWR sky130_fd_sc_hd__decap_3
XFILLER_49_585 VGND VGND VPWR VPWR sky130_fd_sc_hd__decap_3
XFILLER_76_360 VGND VGND VPWR VPWR sky130_fd_sc_hd__decap_3
XFILLER_83_319 VGND VGND VPWR VPWR sky130_fd_sc_hd__decap_3
XFILLER_36_224 VGND VGND VPWR VPWR sky130_fd_sc_hd__decap_3
XFILLER_64_533 VGND VGND VPWR VPWR sky130_fd_sc_hd__decap_3
XFILLER_24_408 VGND VGND VPWR VPWR sky130_fd_sc_hd__fill_1
XFILLER_64_566 VGND VGND VPWR VPWR sky130_fd_sc_hd__decap_3
XFILLER_36_279 VGND VGND VPWR VPWR sky130_fd_sc_hd__fill_1
XFILLER_51_205 VGND VGND VPWR VPWR sky130_fd_sc_hd__decap_3
X_4961_ _4961_/A _5662_/C _4961_/C VGND VGND VPWR VPWR _4961_/X sky130_fd_sc_hd__or3_4
XTAP_TAPCELL_ROW_19_477 VGND VPWR sky130_fd_sc_hd__tapvpwrvgnd_1
X_6700_ _7398_/CLK _6700_/D VGND VGND VPWR VPWR _6700_/Q sky130_fd_sc_hd__dfxtp_2
X_4892_ _4884_/X _4886_/X _4887_/Y _4891_/X VGND VGND VPWR VPWR _5656_/B sky130_fd_sc_hd__a31o_2
X_3912_ _6905_/Q _3918_/A2 _3922_/B1 _6897_/Q VGND VGND VPWR VPWR _3912_/X sky130_fd_sc_hd__a22o_2
XFILLER_20_625 VGND VGND VPWR VPWR sky130_fd_sc_hd__decap_3
XFILLER_32_463 VGND VGND VPWR VPWR sky130_fd_sc_hd__decap_3
X_6631_ _6632_/A VGND VGND VPWR VPWR _6631_/Y sky130_fd_sc_hd__inv_2
X_3843_ _6699_/Q _3893_/B1 _3887_/B1 _6877_/Q _3842_/X VGND VGND VPWR VPWR _3843_/X
+ sky130_fd_sc_hd__a221o_2
XFILLER_20_669 VGND VGND VPWR VPWR sky130_fd_sc_hd__decap_3
X_6562_ _6570_/A VGND VGND VPWR VPWR _6562_/Y sky130_fd_sc_hd__inv_2
X_3774_ _6757_/Q _3889_/B1 _3902_/B1 _6769_/Q _3773_/X VGND VGND VPWR VPWR _3774_/X
+ sky130_fd_sc_hd__a221o_2
XFILLER_8_180 VGND VGND VPWR VPWR sky130_fd_sc_hd__fill_1
X_6493_ _6620_/A VGND VGND VPWR VPWR _6493_/Y sky130_fd_sc_hd__inv_2
Xclkbuf_leaf_8_clk clkbuf_leaf_9_clk/A VGND VGND VPWR VPWR _7398_/CLK sky130_fd_sc_hd__clkbuf_16
XFILLER_113_240 VGND VGND VPWR VPWR sky130_fd_sc_hd__decap_3
XFILLER_87_603 VGND VGND VPWR VPWR sky130_fd_sc_hd__decap_3
X_7114_ _7368_/CLK _7114_/D _6394_/Y VGND VGND VPWR VPWR _7114_/Q sky130_fd_sc_hd__dfrtp_2
Xoutput477 _5656_/A VGND VGND VPWR VPWR alu_result_out[26] sky130_fd_sc_hd__clkdlybuf4s25_1
Xoutput466 _4973_/B VGND VGND VPWR VPWR alu_result_out[16] sky130_fd_sc_hd__clkdlybuf4s25_1
X_5375_ _5375_/A0 _4806_/X _5383_/S VGND VGND VPWR VPWR _7145_/D sky130_fd_sc_hd__mux2_2
XFILLER_99_452 VGND VGND VPWR VPWR sky130_fd_sc_hd__fill_2
XFILLER_113_251 VGND VGND VPWR VPWR sky130_fd_sc_hd__decap_3
XFILLER_113_273 VGND VGND VPWR VPWR sky130_fd_sc_hd__decap_3
Xoutput499 _5161_/A VGND VGND VPWR VPWR instruction_out[18] sky130_fd_sc_hd__clkdlybuf4s25_1
Xoutput488 _5658_/D VGND VGND VPWR VPWR alu_result_out[7] sky130_fd_sc_hd__clkdlybuf4s25_1
X_4326_ _7013_/Q _4601_/S _4322_/X _4325_/X VGND VGND VPWR VPWR _4327_/B sky130_fd_sc_hd__a211o_2
XFILLER_86_124 VGND VGND VPWR VPWR sky130_fd_sc_hd__decap_3
XFILLER_87_647 VGND VGND VPWR VPWR sky130_fd_sc_hd__decap_3
X_7045_ _7362_/CLK _7045_/D _6325_/Y VGND VGND VPWR VPWR _7045_/Q sky130_fd_sc_hd__dfrtp_2
X_4257_ _4626_/B _4626_/C _4256_/C VGND VGND VPWR VPWR _4988_/B sky130_fd_sc_hd__a21oi_2
XFILLER_67_360 VGND VGND VPWR VPWR sky130_fd_sc_hd__decap_3
XFILLER_86_168 VGND VGND VPWR VPWR sky130_fd_sc_hd__decap_3
X_4188_ _7359_/Q _4261_/A2 _4187_/X _4347_/C1 VGND VGND VPWR VPWR _4188_/X sky130_fd_sc_hd__a211o_2
XFILLER_103_12 VGND VGND VPWR VPWR sky130_fd_sc_hd__decap_3
XFILLER_27_235 VGND VGND VPWR VPWR sky130_fd_sc_hd__decap_3
XFILLER_55_544 VGND VGND VPWR VPWR sky130_fd_sc_hd__fill_1
XFILLER_67_393 VGND VGND VPWR VPWR sky130_fd_sc_hd__fill_2
XFILLER_27_268 VGND VGND VPWR VPWR sky130_fd_sc_hd__decap_3
XFILLER_82_330 VGND VGND VPWR VPWR sky130_fd_sc_hd__decap_3
XFILLER_82_363 VGND VGND VPWR VPWR sky130_fd_sc_hd__fill_1
XFILLER_94_190 VGND VGND VPWR VPWR sky130_fd_sc_hd__decap_3
XFILLER_103_78 VGND VGND VPWR VPWR sky130_fd_sc_hd__decap_3
XFILLER_42_227 VGND VGND VPWR VPWR sky130_fd_sc_hd__decap_3
XFILLER_55_588 VGND VGND VPWR VPWR sky130_fd_sc_hd__decap_3
XFILLER_63_27 VGND VGND VPWR VPWR sky130_fd_sc_hd__decap_3
XFILLER_63_38 VGND VGND VPWR VPWR sky130_fd_sc_hd__fill_2
XFILLER_70_558 VGND VGND VPWR VPWR sky130_fd_sc_hd__decap_3
XFILLER_11_603 VGND VGND VPWR VPWR sky130_fd_sc_hd__decap_3
XFILLER_23_452 VGND VGND VPWR VPWR sky130_fd_sc_hd__decap_3
X_6829_ _6954_/CLK _6829_/D VGND VGND VPWR VPWR _6829_/Q sky130_fd_sc_hd__dfxtp_2
XFILLER_11_647 VGND VGND VPWR VPWR sky130_fd_sc_hd__decap_3
XFILLER_23_485 VGND VGND VPWR VPWR sky130_fd_sc_hd__decap_3
XFILLER_7_629 VGND VGND VPWR VPWR sky130_fd_sc_hd__decap_3
XFILLER_109_535 VGND VGND VPWR VPWR sky130_fd_sc_hd__decap_3
XFILLER_109_579 VGND VGND VPWR VPWR sky130_fd_sc_hd__decap_3
XFILLER_12_64 VGND VGND VPWR VPWR sky130_fd_sc_hd__decap_3
XFILLER_5_3 VGND VGND VPWR VPWR sky130_fd_sc_hd__decap_3
XFILLER_88_57 VGND VGND VPWR VPWR sky130_fd_sc_hd__fill_2
XFILLER_77_113 VGND VGND VPWR VPWR sky130_fd_sc_hd__decap_3
XFILLER_78_625 VGND VGND VPWR VPWR sky130_fd_sc_hd__decap_3
XFILLER_104_295 VGND VGND VPWR VPWR sky130_fd_sc_hd__decap_3
XFILLER_78_669 VGND VGND VPWR VPWR sky130_fd_sc_hd__decap_3
XFILLER_77_179 VGND VGND VPWR VPWR sky130_fd_sc_hd__fill_1
XFILLER_93_606 VGND VGND VPWR VPWR sky130_fd_sc_hd__decap_3
XFILLER_93_617 VGND VGND VPWR VPWR sky130_fd_sc_hd__decap_3
XFILLER_18_224 VGND VGND VPWR VPWR sky130_fd_sc_hd__decap_3
XFILLER_92_116 VGND VGND VPWR VPWR sky130_fd_sc_hd__decap_3
XFILLER_92_127 VGND VGND VPWR VPWR sky130_fd_sc_hd__decap_3
XFILLER_37_83 VGND VGND VPWR VPWR sky130_fd_sc_hd__decap_3
XFILLER_73_330 VGND VGND VPWR VPWR sky130_fd_sc_hd__decap_3
XFILLER_73_352 VGND VGND VPWR VPWR sky130_fd_sc_hd__decap_3
XFILLER_26_290 VGND VGND VPWR VPWR sky130_fd_sc_hd__decap_3
XFILLER_33_249 VGND VGND VPWR VPWR sky130_fd_sc_hd__decap_3
XTAP_TAPCELL_ROW_16_447 VGND VPWR sky130_fd_sc_hd__tapvpwrvgnd_1
XTAP_TAPCELL_ROW_44_778 VGND VPWR sky130_fd_sc_hd__tapvpwrvgnd_1
XFILLER_41_293 VGND VGND VPWR VPWR sky130_fd_sc_hd__decap_3
XFILLER_115_505 VGND VGND VPWR VPWR sky130_fd_sc_hd__decap_3
XFILLER_6_640 VGND VGND VPWR VPWR sky130_fd_sc_hd__decap_3
XFILLER_6_651 VGND VGND VPWR VPWR sky130_fd_sc_hd__decap_3
X_3490_ _7119_/Q _4279_/B1 _3489_/X _3556_/A VGND VGND VPWR VPWR _3490_/X sky130_fd_sc_hd__a211o_2
XFILLER_115_538 VGND VGND VPWR VPWR sky130_fd_sc_hd__decap_3
XFILLER_6_684 VGND VGND VPWR VPWR sky130_fd_sc_hd__decap_3
XFILLER_69_603 VGND VGND VPWR VPWR sky130_fd_sc_hd__decap_3
XFILLER_68_102 VGND VGND VPWR VPWR sky130_fd_sc_hd__decap_3
XPHY_EDGE_ROW_87_Left_204 VGND VGND VPWR VPWR sky130_fd_sc_hd__decap_3
XFILLER_110_210 VGND VGND VPWR VPWR sky130_fd_sc_hd__decap_3
XFILLER_69_647 VGND VGND VPWR VPWR sky130_fd_sc_hd__decap_3
XFILLER_96_444 VGND VGND VPWR VPWR sky130_fd_sc_hd__decap_3
X_5091_ _6985_/Q _5068_/C _6986_/Q VGND VGND VPWR VPWR _5092_/B sky130_fd_sc_hd__a21o_2
X_4111_ _4109_/X _4111_/B VGND VGND VPWR VPWR _4845_/A sky130_fd_sc_hd__nand2b_2
XFILLER_68_168 VGND VGND VPWR VPWR sky130_fd_sc_hd__decap_3
XFILLER_84_628 VGND VGND VPWR VPWR sky130_fd_sc_hd__decap_3
X_4042_ _7341_/Q _3947_/S _4406_/A2 _7373_/Q _4429_/C1 VGND VGND VPWR VPWR _4042_/X
+ sky130_fd_sc_hd__a221o_2
XFILLER_49_371 VGND VGND VPWR VPWR sky130_fd_sc_hd__fill_2
XFILLER_49_382 VGND VGND VPWR VPWR sky130_fd_sc_hd__decap_3
XFILLER_83_116 VGND VGND VPWR VPWR sky130_fd_sc_hd__decap_3
XFILLER_76_190 VGND VGND VPWR VPWR sky130_fd_sc_hd__decap_3
XFILLER_24_216 VGND VGND VPWR VPWR sky130_fd_sc_hd__decap_3
XFILLER_37_588 VGND VGND VPWR VPWR sky130_fd_sc_hd__decap_3
XFILLER_52_514 VGND VGND VPWR VPWR sky130_fd_sc_hd__decap_3
XFILLER_64_374 VGND VGND VPWR VPWR sky130_fd_sc_hd__decap_3
XFILLER_92_672 VGND VGND VPWR VPWR sky130_fd_sc_hd__decap_3
XTAP_TAPCELL_ROW_65_1028 VGND VPWR sky130_fd_sc_hd__tapvpwrvgnd_1
XFILLER_24_249 VGND VGND VPWR VPWR sky130_fd_sc_hd__decap_3
XFILLER_91_182 VGND VGND VPWR VPWR sky130_fd_sc_hd__fill_1
X_4944_ _5010_/A _4944_/B _4944_/C VGND VGND VPWR VPWR _4944_/X sky130_fd_sc_hd__or3_2
XPHY_EDGE_ROW_96_Left_213 VGND VGND VPWR VPWR sky130_fd_sc_hd__decap_3
X_4875_ _4842_/X _4871_/Y _4874_/X VGND VGND VPWR VPWR _5663_/C sky130_fd_sc_hd__a21bo_2
XFILLER_20_455 VGND VGND VPWR VPWR sky130_fd_sc_hd__decap_3
X_6614_ _6614_/A VGND VGND VPWR VPWR _6614_/Y sky130_fd_sc_hd__inv_2
X_3826_ _6731_/Q _3903_/B1 _3922_/B1 _6743_/Q _3825_/X VGND VGND VPWR VPWR _3826_/X
+ sky130_fd_sc_hd__a221o_2
X_6545_ _6643_/A VGND VGND VPWR VPWR _6545_/Y sky130_fd_sc_hd__inv_2
X_3757_ _3757_/A0 _3756_/X _4799_/A VGND VGND VPWR VPWR _7396_/D sky130_fd_sc_hd__mux2_2
XFILLER_106_516 VGND VGND VPWR VPWR sky130_fd_sc_hd__decap_3
X_6476_ _6637_/A VGND VGND VPWR VPWR _6476_/Y sky130_fd_sc_hd__inv_2
X_5427_ _5427_/A0 _5156_/X _5429_/S VGND VGND VPWR VPWR _7120_/D sky130_fd_sc_hd__mux2_2
XTAP_TAPCELL_ROW_76_1168 VGND VPWR sky130_fd_sc_hd__tapvpwrvgnd_1
XFILLER_114_560 VGND VGND VPWR VPWR sky130_fd_sc_hd__decap_3
XFILLER_58_27 VGND VGND VPWR VPWR sky130_fd_sc_hd__fill_1
XFILLER_87_411 VGND VGND VPWR VPWR sky130_fd_sc_hd__decap_3
X_5358_ _5358_/A0 _5156_/X _7412_/A VGND VGND VPWR VPWR _7152_/D sky130_fd_sc_hd__mux2_2
XFILLER_59_113 VGND VGND VPWR VPWR sky130_fd_sc_hd__decap_3
XFILLER_87_455 VGND VGND VPWR VPWR sky130_fd_sc_hd__fill_1
X_4309_ _7128_/Q _3407_/X _4307_/X _4308_/X VGND VGND VPWR VPWR _4311_/B sky130_fd_sc_hd__a211o_2
XFILLER_28_500 VGND VGND VPWR VPWR sky130_fd_sc_hd__decap_3
XFILLER_47_308 VGND VGND VPWR VPWR sky130_fd_sc_hd__decap_3
XFILLER_75_606 VGND VGND VPWR VPWR sky130_fd_sc_hd__decap_3
XFILLER_75_617 VGND VGND VPWR VPWR sky130_fd_sc_hd__decap_3
X_7028_ _7383_/CLK _7028_/D _6308_/Y VGND VGND VPWR VPWR _7028_/Q sky130_fd_sc_hd__dfrtp_2
XFILLER_114_44 VGND VGND VPWR VPWR sky130_fd_sc_hd__decap_3
XFILLER_28_533 VGND VGND VPWR VPWR sky130_fd_sc_hd__decap_3
XFILLER_74_127 VGND VGND VPWR VPWR sky130_fd_sc_hd__decap_3
XFILLER_114_77 VGND VGND VPWR VPWR sky130_fd_sc_hd__decap_3
XFILLER_114_88 VGND VGND VPWR VPWR sky130_fd_sc_hd__decap_3
XFILLER_28_566 VGND VGND VPWR VPWR sky130_fd_sc_hd__decap_3
XFILLER_74_26 VGND VGND VPWR VPWR sky130_fd_sc_hd__fill_2
XFILLER_83_650 VGND VGND VPWR VPWR sky130_fd_sc_hd__decap_3
XFILLER_43_514 VGND VGND VPWR VPWR sky130_fd_sc_hd__fill_2
XFILLER_15_249 VGND VGND VPWR VPWR sky130_fd_sc_hd__decap_3
XFILLER_55_396 VGND VGND VPWR VPWR sky130_fd_sc_hd__decap_3
XFILLER_70_333 VGND VGND VPWR VPWR sky130_fd_sc_hd__fill_1
XFILLER_82_182 VGND VGND VPWR VPWR sky130_fd_sc_hd__decap_3
XTAP_TAPCELL_ROW_87_1297 VGND VPWR sky130_fd_sc_hd__tapvpwrvgnd_1
XTAP_TAPCELL_ROW_13_406 VGND VPWR sky130_fd_sc_hd__tapvpwrvgnd_1
XFILLER_11_411 VGND VGND VPWR VPWR sky130_fd_sc_hd__decap_3
XFILLER_23_260 VGND VGND VPWR VPWR sky130_fd_sc_hd__decap_3
XFILLER_51_591 VGND VGND VPWR VPWR sky130_fd_sc_hd__decap_3
XFILLER_90_47 VGND VGND VPWR VPWR sky130_fd_sc_hd__fill_1
XTAP_TAPCELL_ROW_41_748 VGND VPWR sky130_fd_sc_hd__tapvpwrvgnd_1
XFILLER_11_466 VGND VGND VPWR VPWR sky130_fd_sc_hd__decap_3
XFILLER_23_293 VGND VGND VPWR VPWR sky130_fd_sc_hd__decap_3
XFILLER_23_85 VGND VGND VPWR VPWR sky130_fd_sc_hd__decap_3
XFILLER_109_365 VGND VGND VPWR VPWR sky130_fd_sc_hd__decap_3
XFILLER_109_387 VGND VGND VPWR VPWR sky130_fd_sc_hd__decap_3
XFILLER_3_632 VGND VGND VPWR VPWR sky130_fd_sc_hd__decap_3
XFILLER_112_519 VGND VGND VPWR VPWR sky130_fd_sc_hd__decap_3
XFILLER_2_164 VGND VGND VPWR VPWR sky130_fd_sc_hd__decap_3
XFILLER_3_665 VGND VGND VPWR VPWR sky130_fd_sc_hd__decap_3
XFILLER_3_676 VGND VGND VPWR VPWR sky130_fd_sc_hd__decap_3
XFILLER_105_582 VGND VGND VPWR VPWR sky130_fd_sc_hd__decap_3
XFILLER_2_197 VGND VGND VPWR VPWR sky130_fd_sc_hd__decap_3
XFILLER_66_628 VGND VGND VPWR VPWR sky130_fd_sc_hd__decap_3
XFILLER_78_477 VGND VGND VPWR VPWR sky130_fd_sc_hd__decap_3
XFILLER_78_488 VGND VGND VPWR VPWR sky130_fd_sc_hd__decap_3
XFILLER_19_522 VGND VGND VPWR VPWR sky130_fd_sc_hd__decap_3
XFILLER_48_93 VGND VGND VPWR VPWR sky130_fd_sc_hd__decap_3
XFILLER_65_116 VGND VGND VPWR VPWR sky130_fd_sc_hd__fill_2
XFILLER_65_138 VGND VGND VPWR VPWR sky130_fd_sc_hd__decap_3
XFILLER_93_425 VGND VGND VPWR VPWR sky130_fd_sc_hd__decap_3
Xsingle_cycle_cpu_578 VGND VGND VPWR VPWR single_cycle_cpu_578/HI instruction_out[31]
+ sky130_fd_sc_hd__conb_1
XTAP_TAPCELL_ROW_49_837 VGND VPWR sky130_fd_sc_hd__tapvpwrvgnd_1
XFILLER_19_555 VGND VGND VPWR VPWR sky130_fd_sc_hd__decap_3
XFILLER_58_190 VGND VGND VPWR VPWR sky130_fd_sc_hd__decap_3
XFILLER_81_609 VGND VGND VPWR VPWR sky130_fd_sc_hd__decap_3
XFILLER_19_588 VGND VGND VPWR VPWR sky130_fd_sc_hd__decap_3
XFILLER_46_363 VGND VGND VPWR VPWR sky130_fd_sc_hd__fill_1
XFILLER_61_311 VGND VGND VPWR VPWR sky130_fd_sc_hd__fill_1
XFILLER_74_672 VGND VGND VPWR VPWR sky130_fd_sc_hd__decap_3
XFILLER_34_536 VGND VGND VPWR VPWR sky130_fd_sc_hd__fill_1
XFILLER_73_193 VGND VGND VPWR VPWR sky130_fd_sc_hd__fill_2
XTAP_TAPCELL_ROW_29_594 VGND VPWR sky130_fd_sc_hd__tapvpwrvgnd_1
XFILLER_61_366 VGND VGND VPWR VPWR sky130_fd_sc_hd__decap_3
X_4660_ _4720_/A _4655_/X _4658_/A VGND VGND VPWR VPWR _4660_/X sky130_fd_sc_hd__a21bo_2
XFILLER_9_87 VGND VGND VPWR VPWR sky130_fd_sc_hd__fill_1
X_3611_ _5057_/A _3611_/B VGND VGND VPWR VPWR _3611_/Y sky130_fd_sc_hd__nor2_2
X_6330_ _6652_/A VGND VGND VPWR VPWR _6330_/Y sky130_fd_sc_hd__inv_2
X_4591_ _4591_/A _4591_/B VGND VGND VPWR VPWR _7285_/D sky130_fd_sc_hd__and2_2
Xhold905 _7057_/Q VGND VGND VPWR VPWR _7057_/D sky130_fd_sc_hd__dlygate4sd3_1
Xhold916 _6713_/Q VGND VGND VPWR VPWR hold916/X sky130_fd_sc_hd__dlygate4sd3_1
Xhold927 _6687_/Q VGND VGND VPWR VPWR hold927/X sky130_fd_sc_hd__dlygate4sd3_1
XFILLER_103_508 VGND VGND VPWR VPWR sky130_fd_sc_hd__decap_3
Xhold949 _7049_/Q VGND VGND VPWR VPWR hold949/X sky130_fd_sc_hd__dlygate4sd3_1
Xhold938 _7046_/Q VGND VGND VPWR VPWR hold938/X sky130_fd_sc_hd__dlygate4sd3_1
X_6261_ _6629_/A VGND VGND VPWR VPWR _6261_/Y sky130_fd_sc_hd__inv_2
X_3473_ _7312_/Q _3996_/S _4338_/B1 _7344_/Q _4248_/A VGND VGND VPWR VPWR _3473_/X
+ sky130_fd_sc_hd__a221o_2
XFILLER_96_230 VGND VGND VPWR VPWR sky130_fd_sc_hd__decap_3
XFILLER_111_541 VGND VGND VPWR VPWR sky130_fd_sc_hd__decap_3
XFILLER_57_606 VGND VGND VPWR VPWR sky130_fd_sc_hd__decap_3
XFILLER_57_617 VGND VGND VPWR VPWR sky130_fd_sc_hd__decap_3
XFILLER_111_585 VGND VGND VPWR VPWR sky130_fd_sc_hd__decap_3
XFILLER_96_285 VGND VGND VPWR VPWR sky130_fd_sc_hd__decap_3
X_5074_ _4852_/A _5073_/A _5073_/Y _4811_/C VGND VGND VPWR VPWR _5075_/C sky130_fd_sc_hd__a2bb2o_2
XTAP_TAPCELL_ROW_71_1098 VGND VPWR sky130_fd_sc_hd__tapvpwrvgnd_1
XFILLER_37_341 VGND VGND VPWR VPWR sky130_fd_sc_hd__decap_3
XFILLER_49_190 VGND VGND VPWR VPWR sky130_fd_sc_hd__decap_3
XFILLER_65_650 VGND VGND VPWR VPWR sky130_fd_sc_hd__decap_3
XFILLER_25_503 VGND VGND VPWR VPWR sky130_fd_sc_hd__fill_1
XFILLER_37_352 VGND VGND VPWR VPWR sky130_fd_sc_hd__fill_1
XFILLER_37_374 VGND VGND VPWR VPWR sky130_fd_sc_hd__decap_3
XFILLER_37_385 VGND VGND VPWR VPWR sky130_fd_sc_hd__decap_3
XFILLER_52_300 VGND VGND VPWR VPWR sky130_fd_sc_hd__fill_1
XFILLER_71_119 VGND VGND VPWR VPWR sky130_fd_sc_hd__decap_3
XFILLER_44_29 VGND VGND VPWR VPWR sky130_fd_sc_hd__fill_1
XFILLER_80_631 VGND VGND VPWR VPWR sky130_fd_sc_hd__decap_3
XFILLER_92_491 VGND VGND VPWR VPWR sky130_fd_sc_hd__fill_1
XFILLER_52_355 VGND VGND VPWR VPWR sky130_fd_sc_hd__decap_3
XFILLER_80_675 VGND VGND VPWR VPWR sky130_fd_sc_hd__decap_3
XFILLER_100_24 VGND VGND VPWR VPWR sky130_fd_sc_hd__decap_3
XFILLER_12_219 VGND VGND VPWR VPWR sky130_fd_sc_hd__decap_3
XFILLER_33_591 VGND VGND VPWR VPWR sky130_fd_sc_hd__decap_3
X_4927_ _4927_/A _4927_/B _5656_/C VGND VGND VPWR VPWR _4927_/X sky130_fd_sc_hd__or3_2
X_4858_ _6999_/Q _4858_/B VGND VGND VPWR VPWR _4870_/A sky130_fd_sc_hd__and2_2
XFILLER_20_274 VGND VGND VPWR VPWR sky130_fd_sc_hd__decap_3
X_3809_ _6836_/Q _3879_/B1 _3892_/B1 _6841_/Q VGND VGND VPWR VPWR _3809_/X sky130_fd_sc_hd__a22o_2
XFILLER_109_11 VGND VGND VPWR VPWR sky130_fd_sc_hd__decap_3
XFILLER_20_296 VGND VGND VPWR VPWR sky130_fd_sc_hd__decap_3
X_4789_ _5057_/A _4412_/B _4413_/A _4852_/A _4788_/Y VGND VGND VPWR VPWR _4789_/X
+ sky130_fd_sc_hd__o221a_2
XFILLER_109_44 VGND VGND VPWR VPWR sky130_fd_sc_hd__decap_3
X_6528_ _6633_/A VGND VGND VPWR VPWR _6528_/Y sky130_fd_sc_hd__inv_2
XFILLER_107_6 VGND VGND VPWR VPWR sky130_fd_sc_hd__decap_3
XFILLER_69_15 VGND VGND VPWR VPWR sky130_fd_sc_hd__decap_3
X_6459_ _6494_/A VGND VGND VPWR VPWR _6459_/Y sky130_fd_sc_hd__inv_2
XFILLER_0_657 VGND VGND VPWR VPWR sky130_fd_sc_hd__decap_3
XFILLER_0_679 VGND VGND VPWR VPWR sky130_fd_sc_hd__decap_3
XFILLER_102_563 VGND VGND VPWR VPWR sky130_fd_sc_hd__decap_3
XFILLER_48_628 VGND VGND VPWR VPWR sky130_fd_sc_hd__decap_3
XFILLER_75_436 VGND VGND VPWR VPWR sky130_fd_sc_hd__decap_3
XTAP_TAPCELL_ROW_89_1315 VGND VPWR sky130_fd_sc_hd__tapvpwrvgnd_1
XFILLER_63_609 VGND VGND VPWR VPWR sky130_fd_sc_hd__decap_3
XTAP_TAPCELL_ROW_46_807 VGND VPWR sky130_fd_sc_hd__tapvpwrvgnd_1
XFILLER_16_503 VGND VGND VPWR VPWR sky130_fd_sc_hd__decap_3
XFILLER_16_514 VGND VGND VPWR VPWR sky130_fd_sc_hd__decap_3
XFILLER_56_672 VGND VGND VPWR VPWR sky130_fd_sc_hd__decap_3
XFILLER_62_108 VGND VGND VPWR VPWR sky130_fd_sc_hd__fill_2
XFILLER_90_417 VGND VGND VPWR VPWR sky130_fd_sc_hd__decap_3
XFILLER_16_536 VGND VGND VPWR VPWR sky130_fd_sc_hd__decap_3
XFILLER_43_311 VGND VGND VPWR VPWR sky130_fd_sc_hd__decap_3
XFILLER_71_620 VGND VGND VPWR VPWR sky130_fd_sc_hd__decap_3
XFILLER_71_653 VGND VGND VPWR VPWR sky130_fd_sc_hd__decap_3
XFILLER_16_569 VGND VGND VPWR VPWR sky130_fd_sc_hd__decap_3
XTAP_TAPCELL_ROW_26_564 VGND VPWR sky130_fd_sc_hd__tapvpwrvgnd_1
XFILLER_70_174 VGND VGND VPWR VPWR sky130_fd_sc_hd__decap_3
XTAP_TAPCELL_ROW_54_895 VGND VPWR sky130_fd_sc_hd__tapvpwrvgnd_1
XFILLER_11_274 VGND VGND VPWR VPWR sky130_fd_sc_hd__decap_3
XFILLER_7_234 VGND VGND VPWR VPWR sky130_fd_sc_hd__fill_1
XFILLER_109_162 VGND VGND VPWR VPWR sky130_fd_sc_hd__decap_3
XFILLER_7_289 VGND VGND VPWR VPWR sky130_fd_sc_hd__decap_3
XFILLER_3_462 VGND VGND VPWR VPWR sky130_fd_sc_hd__decap_3
XFILLER_98_539 VGND VGND VPWR VPWR sky130_fd_sc_hd__decap_3
XFILLER_98_528 VGND VGND VPWR VPWR sky130_fd_sc_hd__decap_3
XFILLER_112_327 VGND VGND VPWR VPWR sky130_fd_sc_hd__decap_3
XFILLER_3_484 VGND VGND VPWR VPWR sky130_fd_sc_hd__decap_3
XFILLER_39_606 VGND VGND VPWR VPWR sky130_fd_sc_hd__decap_3
XFILLER_39_617 VGND VGND VPWR VPWR sky130_fd_sc_hd__decap_3
XFILLER_59_81 VGND VGND VPWR VPWR sky130_fd_sc_hd__decap_3
XFILLER_66_414 VGND VGND VPWR VPWR sky130_fd_sc_hd__decap_3
XFILLER_93_211 VGND VGND VPWR VPWR sky130_fd_sc_hd__decap_3
XFILLER_47_650 VGND VGND VPWR VPWR sky130_fd_sc_hd__decap_3
XFILLER_34_300 VGND VGND VPWR VPWR sky130_fd_sc_hd__decap_3
XFILLER_46_160 VGND VGND VPWR VPWR sky130_fd_sc_hd__decap_3
XTAP_TAPCELL_ROW_109_1562 VGND VPWR sky130_fd_sc_hd__tapvpwrvgnd_1
XFILLER_62_631 VGND VGND VPWR VPWR sky130_fd_sc_hd__decap_3
XFILLER_74_491 VGND VGND VPWR VPWR sky130_fd_sc_hd__decap_3
XFILLER_62_675 VGND VGND VPWR VPWR sky130_fd_sc_hd__decap_3
XFILLER_61_163 VGND VGND VPWR VPWR sky130_fd_sc_hd__decap_3
XFILLER_15_591 VGND VGND VPWR VPWR sky130_fd_sc_hd__decap_3
X_4712_ _7007_/Q _4738_/A VGND VGND VPWR VPWR _4731_/B sky130_fd_sc_hd__nand2_2
XFILLER_30_561 VGND VGND VPWR VPWR sky130_fd_sc_hd__decap_3
X_4643_ _4888_/A _4125_/X _4126_/A VGND VGND VPWR VPWR _4643_/Y sky130_fd_sc_hd__a21oi_2
X_7362_ _7362_/CLK _7362_/D _6642_/Y VGND VGND VPWR VPWR _7362_/Q sky130_fd_sc_hd__dfrtp_2
Xhold702 _6764_/Q VGND VGND VPWR VPWR _6764_/D sky130_fd_sc_hd__dlygate4sd3_1
X_7293_ _7322_/CLK _7293_/D _6573_/Y VGND VGND VPWR VPWR _7293_/Q sky130_fd_sc_hd__dfrtp_2
Xhold713 _6948_/Q VGND VGND VPWR VPWR _6948_/D sky130_fd_sc_hd__dlygate4sd3_1
Xhold724 _6730_/Q VGND VGND VPWR VPWR _6730_/D sky130_fd_sc_hd__dlygate4sd3_1
Xhold735 _6941_/Q VGND VGND VPWR VPWR _6941_/D sky130_fd_sc_hd__dlygate4sd3_1
Xhold746 _6855_/Q VGND VGND VPWR VPWR _6855_/D sky130_fd_sc_hd__dlygate4sd3_1
X_6313_ _6625_/A VGND VGND VPWR VPWR _6313_/Y sky130_fd_sc_hd__inv_2
X_3525_ _3525_/A _3525_/B VGND VGND VPWR VPWR _3609_/B sky130_fd_sc_hd__and2_2
XFILLER_103_305 VGND VGND VPWR VPWR sky130_fd_sc_hd__decap_3
XFILLER_103_316 VGND VGND VPWR VPWR sky130_fd_sc_hd__decap_3
XFILLER_115_143 VGND VGND VPWR VPWR sky130_fd_sc_hd__decap_3
XFILLER_115_165 VGND VGND VPWR VPWR sky130_fd_sc_hd__decap_3
Xhold757 _6888_/Q VGND VGND VPWR VPWR _6888_/D sky130_fd_sc_hd__dlygate4sd3_1
Xhold768 _6972_/Q VGND VGND VPWR VPWR _6972_/D sky130_fd_sc_hd__dlygate4sd3_1
Xhold779 _6849_/Q VGND VGND VPWR VPWR _6849_/D sky130_fd_sc_hd__dlygate4sd3_1
XTAP_TAPCELL_ROW_73_1127 VGND VPWR sky130_fd_sc_hd__tapvpwrvgnd_1
XFILLER_103_349 VGND VGND VPWR VPWR sky130_fd_sc_hd__decap_3
XFILLER_115_187 VGND VGND VPWR VPWR sky130_fd_sc_hd__decap_3
X_3456_ _7011_/Q _4601_/S _3448_/X _3455_/X VGND VGND VPWR VPWR _3456_/X sky130_fd_sc_hd__a211o_2
XFILLER_97_550 VGND VGND VPWR VPWR sky130_fd_sc_hd__decap_3
XFILLER_97_561 VGND VGND VPWR VPWR sky130_fd_sc_hd__decap_3
X_3387_ _3385_/Y _3386_/Y _4471_/S _3399_/B VGND VGND VPWR VPWR _3429_/B sky130_fd_sc_hd__a211o_2
XFILLER_111_360 VGND VGND VPWR VPWR sky130_fd_sc_hd__decap_3
XFILLER_57_425 VGND VGND VPWR VPWR sky130_fd_sc_hd__decap_3
XFILLER_69_263 VGND VGND VPWR VPWR sky130_fd_sc_hd__decap_3
XFILLER_97_594 VGND VGND VPWR VPWR sky130_fd_sc_hd__decap_3
X_5126_ _5126_/A0 _5125_/Y _5159_/S VGND VGND VPWR VPWR _7253_/D sky130_fd_sc_hd__mux2_2
XFILLER_111_393 VGND VGND VPWR VPWR sky130_fd_sc_hd__decap_3
XFILLER_45_609 VGND VGND VPWR VPWR sky130_fd_sc_hd__decap_3
XFILLER_57_447 VGND VGND VPWR VPWR sky130_fd_sc_hd__fill_1
XFILLER_84_222 VGND VGND VPWR VPWR sky130_fd_sc_hd__decap_3
X_5057_ _5057_/A _5057_/B VGND VGND VPWR VPWR _5057_/Y sky130_fd_sc_hd__nor2_2
XFILLER_38_672 VGND VGND VPWR VPWR sky130_fd_sc_hd__decap_3
XFILLER_72_417 VGND VGND VPWR VPWR sky130_fd_sc_hd__decap_3
XFILLER_84_277 VGND VGND VPWR VPWR sky130_fd_sc_hd__decap_3
XFILLER_111_12 VGND VGND VPWR VPWR sky130_fd_sc_hd__decap_3
XFILLER_25_333 VGND VGND VPWR VPWR sky130_fd_sc_hd__decap_3
XFILLER_53_620 VGND VGND VPWR VPWR sky130_fd_sc_hd__decap_3
XFILLER_65_491 VGND VGND VPWR VPWR sky130_fd_sc_hd__decap_3
XFILLER_111_45 VGND VGND VPWR VPWR sky130_fd_sc_hd__decap_3
XFILLER_52_141 VGND VGND VPWR VPWR sky130_fd_sc_hd__decap_3
XFILLER_53_653 VGND VGND VPWR VPWR sky130_fd_sc_hd__decap_3
XTAP_TAPCELL_ROW_84_1256 VGND VPWR sky130_fd_sc_hd__tapvpwrvgnd_1
XFILLER_111_78 VGND VGND VPWR VPWR sky130_fd_sc_hd__fill_1
XFILLER_13_528 VGND VGND VPWR VPWR sky130_fd_sc_hd__decap_3
XTAP_TAPCELL_ROW_23_523 VGND VPWR sky130_fd_sc_hd__tapvpwrvgnd_1
XFILLER_40_347 VGND VGND VPWR VPWR sky130_fd_sc_hd__decap_3
XFILLER_71_49 VGND VGND VPWR VPWR sky130_fd_sc_hd__decap_3
XTAP_TAPCELL_ROW_51_865 VGND VPWR sky130_fd_sc_hd__tapvpwrvgnd_1
XFILLER_21_550 VGND VGND VPWR VPWR sky130_fd_sc_hd__decap_3
XFILLER_21_561 VGND VGND VPWR VPWR sky130_fd_sc_hd__decap_3
XFILLER_21_594 VGND VGND VPWR VPWR sky130_fd_sc_hd__decap_3
XFILLER_107_600 VGND VGND VPWR VPWR sky130_fd_sc_hd__decap_3
XFILLER_4_204 VGND VGND VPWR VPWR sky130_fd_sc_hd__decap_3
XFILLER_105_3 VGND VGND VPWR VPWR sky130_fd_sc_hd__decap_3
XFILLER_107_644 VGND VGND VPWR VPWR sky130_fd_sc_hd__decap_3
XFILLER_4_226 VGND VGND VPWR VPWR sky130_fd_sc_hd__decap_3
XFILLER_106_165 VGND VGND VPWR VPWR sky130_fd_sc_hd__decap_3
XFILLER_107_688 VGND VGND VPWR VPWR sky130_fd_sc_hd__decap_3
XTAP_TAPCELL_ROW_95_1396 VGND VPWR sky130_fd_sc_hd__tapvpwrvgnd_1
XFILLER_0_421 VGND VGND VPWR VPWR sky130_fd_sc_hd__decap_3
XFILLER_20_97 VGND VGND VPWR VPWR sky130_fd_sc_hd__fill_1
XFILLER_102_360 VGND VGND VPWR VPWR sky130_fd_sc_hd__decap_3
XFILLER_29_40 VGND VGND VPWR VPWR sky130_fd_sc_hd__decap_3
XFILLER_88_572 VGND VGND VPWR VPWR sky130_fd_sc_hd__decap_3
XPHY_EDGE_ROW_42_Left_159 VGND VGND VPWR VPWR sky130_fd_sc_hd__decap_3
XFILLER_48_458 VGND VGND VPWR VPWR sky130_fd_sc_hd__fill_1
XTAP_TAPCELL_ROW_59_965 VGND VPWR sky130_fd_sc_hd__tapvpwrvgnd_1
XTAP_TAPCELL_ROW_59_954 VGND VPWR sky130_fd_sc_hd__tapvpwrvgnd_1
XFILLER_29_650 VGND VGND VPWR VPWR sky130_fd_sc_hd__decap_3
XFILLER_90_203 VGND VGND VPWR VPWR sky130_fd_sc_hd__decap_3
XFILLER_28_171 VGND VGND VPWR VPWR sky130_fd_sc_hd__decap_3
XFILLER_44_631 VGND VGND VPWR VPWR sky130_fd_sc_hd__decap_3
XFILLER_56_480 VGND VGND VPWR VPWR sky130_fd_sc_hd__decap_3
XFILLER_75_299 VGND VGND VPWR VPWR sky130_fd_sc_hd__decap_3
XFILLER_90_236 VGND VGND VPWR VPWR sky130_fd_sc_hd__fill_1
Xplace406 _4269_/B1 VGND VGND VPWR VPWR _4491_/S sky130_fd_sc_hd__buf_2
Xplace417 _3996_/S VGND VGND VPWR VPWR _3989_/S sky130_fd_sc_hd__buf_2
Xplace428 _3371_/Y VGND VGND VPWR VPWR _4471_/S sky130_fd_sc_hd__buf_2
XTAP_TAPCELL_ROW_3_292 VGND VPWR sky130_fd_sc_hd__tapvpwrvgnd_1
XFILLER_43_130 VGND VGND VPWR VPWR sky130_fd_sc_hd__fill_1
XFILLER_44_675 VGND VGND VPWR VPWR sky130_fd_sc_hd__decap_3
XFILLER_45_50 VGND VGND VPWR VPWR sky130_fd_sc_hd__decap_3
Xplace439 _5117_/A VGND VGND VPWR VPWR _4927_/A sky130_fd_sc_hd__buf_2
XFILLER_16_399 VGND VGND VPWR VPWR sky130_fd_sc_hd__decap_3
XFILLER_45_94 VGND VGND VPWR VPWR sky130_fd_sc_hd__fill_1
XFILLER_71_494 VGND VGND VPWR VPWR sky130_fd_sc_hd__decap_3
XFILLER_91_9 VGND VGND VPWR VPWR sky130_fd_sc_hd__decap_3
XPHY_EDGE_ROW_51_Left_168 VGND VGND VPWR VPWR sky130_fd_sc_hd__decap_3
XFILLER_12_572 VGND VGND VPWR VPWR sky130_fd_sc_hd__decap_3
XFILLER_8_554 VGND VGND VPWR VPWR sky130_fd_sc_hd__decap_3
XFILLER_8_587 VGND VGND VPWR VPWR sky130_fd_sc_hd__fill_1
XFILLER_8_598 VGND VGND VPWR VPWR sky130_fd_sc_hd__decap_3
XANTENNA_4 _7349_/Q VGND VGND VPWR VPWR sky130_fd_sc_hd__diode_2
XFILLER_113_603 VGND VGND VPWR VPWR sky130_fd_sc_hd__decap_3
XFILLER_6_88 VGND VGND VPWR VPWR sky130_fd_sc_hd__decap_3
X_3310_ _5118_/C _3519_/B _3383_/B _5129_/A VGND VGND VPWR VPWR _3310_/Y sky130_fd_sc_hd__a31oi_2
XFILLER_98_314 VGND VGND VPWR VPWR sky130_fd_sc_hd__decap_3
XFILLER_113_647 VGND VGND VPWR VPWR sky130_fd_sc_hd__decap_3
XFILLER_3_270 VGND VGND VPWR VPWR sky130_fd_sc_hd__decap_3
XFILLER_3_281 VGND VGND VPWR VPWR sky130_fd_sc_hd__decap_3
X_4290_ _4283_/X _4288_/X _5647_/B _4649_/A VGND VGND VPWR VPWR _4612_/B sky130_fd_sc_hd__a2bb2o_4
XFILLER_79_561 VGND VGND VPWR VPWR sky130_fd_sc_hd__decap_3
XPHY_EDGE_ROW_60_Left_177 VGND VGND VPWR VPWR sky130_fd_sc_hd__decap_3
XFILLER_79_594 VGND VGND VPWR VPWR sky130_fd_sc_hd__decap_3
XFILLER_94_520 VGND VGND VPWR VPWR sky130_fd_sc_hd__decap_3
XFILLER_27_609 VGND VGND VPWR VPWR sky130_fd_sc_hd__decap_3
XFILLER_66_233 VGND VGND VPWR VPWR sky130_fd_sc_hd__decap_3
XFILLER_94_542 VGND VGND VPWR VPWR sky130_fd_sc_hd__decap_3
XFILLER_54_428 VGND VGND VPWR VPWR sky130_fd_sc_hd__fill_2
XFILLER_66_277 VGND VGND VPWR VPWR sky130_fd_sc_hd__fill_2
XFILLER_94_575 VGND VGND VPWR VPWR sky130_fd_sc_hd__decap_3
XFILLER_35_620 VGND VGND VPWR VPWR sky130_fd_sc_hd__decap_3
XFILLER_66_299 VGND VGND VPWR VPWR sky130_fd_sc_hd__decap_3
XFILLER_81_214 VGND VGND VPWR VPWR sky130_fd_sc_hd__decap_3
XFILLER_81_225 VGND VGND VPWR VPWR sky130_fd_sc_hd__decap_3
X_6931_ _6943_/CLK _6931_/D VGND VGND VPWR VPWR _6931_/Q sky130_fd_sc_hd__dfxtp_2
XFILLER_34_141 VGND VGND VPWR VPWR sky130_fd_sc_hd__fill_2
XFILLER_35_653 VGND VGND VPWR VPWR sky130_fd_sc_hd__decap_3
XFILLER_50_601 VGND VGND VPWR VPWR sky130_fd_sc_hd__decap_3
X_6862_ _6968_/CLK _6862_/D VGND VGND VPWR VPWR _6862_/Q sky130_fd_sc_hd__dfxtp_2
XFILLER_34_174 VGND VGND VPWR VPWR sky130_fd_sc_hd__fill_1
XFILLER_50_634 VGND VGND VPWR VPWR sky130_fd_sc_hd__decap_3
XFILLER_62_483 VGND VGND VPWR VPWR sky130_fd_sc_hd__decap_3
XFILLER_50_645 VGND VGND VPWR VPWR sky130_fd_sc_hd__decap_3
X_6793_ _6954_/CLK _6793_/D VGND VGND VPWR VPWR _6793_/Q sky130_fd_sc_hd__dfxtp_2
XFILLER_50_678 VGND VGND VPWR VPWR sky130_fd_sc_hd__decap_3
X_4626_ _4256_/C _4626_/B _4626_/C VGND VGND VPWR VPWR _4626_/X sky130_fd_sc_hd__and3b_2
X_7345_ _7350_/CLK _7345_/D _6625_/Y VGND VGND VPWR VPWR _7345_/Q sky130_fd_sc_hd__dfrtp_2
XFILLER_116_463 VGND VGND VPWR VPWR sky130_fd_sc_hd__decap_3
XFILLER_1_207 VGND VGND VPWR VPWR sky130_fd_sc_hd__fill_1
XFILLER_103_113 VGND VGND VPWR VPWR sky130_fd_sc_hd__decap_3
XFILLER_104_625 VGND VGND VPWR VPWR sky130_fd_sc_hd__decap_3
XFILLER_89_347 VGND VGND VPWR VPWR sky130_fd_sc_hd__decap_3
X_7276_ _7307_/CLK _7276_/D _6556_/Y VGND VGND VPWR VPWR _7276_/Q sky130_fd_sc_hd__dfrtp_2
Xhold587 _6781_/Q VGND VGND VPWR VPWR _6781_/D sky130_fd_sc_hd__dlygate4sd3_1
X_4488_ _4488_/A0 _4554_/A _4488_/S VGND VGND VPWR VPWR _7335_/D sky130_fd_sc_hd__mux2_2
X_3508_ _3508_/A _3508_/B VGND VGND VPWR VPWR _3508_/Y sky130_fd_sc_hd__nor2_2
XFILLER_104_669 VGND VGND VPWR VPWR sky130_fd_sc_hd__decap_3
XFILLER_106_23 VGND VGND VPWR VPWR sky130_fd_sc_hd__decap_3
Xhold598 _6796_/Q VGND VGND VPWR VPWR _6796_/D sky130_fd_sc_hd__dlygate4sd3_1
X_3439_ _7282_/Q _4300_/B _4318_/B1 _7154_/Q _3438_/X VGND VGND VPWR VPWR _3439_/X
+ sky130_fd_sc_hd__a221o_2
XFILLER_106_56 VGND VGND VPWR VPWR sky130_fd_sc_hd__decap_3
XFILLER_57_200 VGND VGND VPWR VPWR sky130_fd_sc_hd__decap_3
XFILLER_66_27 VGND VGND VPWR VPWR sky130_fd_sc_hd__fill_1
XFILLER_111_190 VGND VGND VPWR VPWR sky130_fd_sc_hd__fill_2
XFILLER_57_222 VGND VGND VPWR VPWR sky130_fd_sc_hd__fill_2
XFILLER_85_542 VGND VGND VPWR VPWR sky130_fd_sc_hd__decap_3
XFILLER_97_391 VGND VGND VPWR VPWR sky130_fd_sc_hd__fill_1
Xhold1210 _7322_/Q VGND VGND VPWR VPWR _4515_/A0 sky130_fd_sc_hd__dlygate4sd3_1
Xhold1221 _7296_/Q VGND VGND VPWR VPWR _4569_/A sky130_fd_sc_hd__dlygate4sd3_1
XFILLER_72_203 VGND VGND VPWR VPWR sky130_fd_sc_hd__decap_3
XFILLER_85_564 VGND VGND VPWR VPWR sky130_fd_sc_hd__decap_3
XTAP_TAPCELL_ROW_56_924 VGND VPWR sky130_fd_sc_hd__tapvpwrvgnd_1
XFILLER_26_631 VGND VGND VPWR VPWR sky130_fd_sc_hd__decap_3
XFILLER_38_480 VGND VGND VPWR VPWR sky130_fd_sc_hd__decap_3
XFILLER_57_299 VGND VGND VPWR VPWR sky130_fd_sc_hd__decap_3
XFILLER_72_236 VGND VGND VPWR VPWR sky130_fd_sc_hd__decap_3
XFILLER_85_597 VGND VGND VPWR VPWR sky130_fd_sc_hd__decap_3
XFILLER_25_141 VGND VGND VPWR VPWR sky130_fd_sc_hd__decap_3
XFILLER_26_675 VGND VGND VPWR VPWR sky130_fd_sc_hd__decap_3
XFILLER_60_409 VGND VGND VPWR VPWR sky130_fd_sc_hd__fill_2
XTAP_TAPCELL_ROW_0_251 VGND VPWR sky130_fd_sc_hd__tapvpwrvgnd_1
XTAP_TAPCELL_ROW_0_240 VGND VPWR sky130_fd_sc_hd__tapvpwrvgnd_1
XFILLER_13_314 VGND VGND VPWR VPWR sky130_fd_sc_hd__decap_3
XFILLER_41_612 VGND VGND VPWR VPWR sky130_fd_sc_hd__decap_3
XFILLER_41_623 VGND VGND VPWR VPWR sky130_fd_sc_hd__decap_3
XFILLER_53_461 VGND VGND VPWR VPWR sky130_fd_sc_hd__decap_3
XTAP_TAPCELL_ROW_36_681 VGND VPWR sky130_fd_sc_hd__tapvpwrvgnd_1
XFILLER_13_358 VGND VGND VPWR VPWR sky130_fd_sc_hd__decap_3
XFILLER_41_656 VGND VGND VPWR VPWR sky130_fd_sc_hd__decap_3
XFILLER_80_280 VGND VGND VPWR VPWR sky130_fd_sc_hd__decap_3
XFILLER_40_155 VGND VGND VPWR VPWR sky130_fd_sc_hd__decap_3
XTAP_TAPCELL_ROW_97_1414 VGND VPWR sky130_fd_sc_hd__tapvpwrvgnd_1
XFILLER_5_502 VGND VGND VPWR VPWR sky130_fd_sc_hd__fill_2
XFILLER_5_535 VGND VGND VPWR VPWR sky130_fd_sc_hd__decap_3
XFILLER_107_441 VGND VGND VPWR VPWR sky130_fd_sc_hd__decap_3
XFILLER_107_452 VGND VGND VPWR VPWR sky130_fd_sc_hd__decap_3
XFILLER_5_579 VGND VGND VPWR VPWR sky130_fd_sc_hd__decap_3
XFILLER_107_485 VGND VGND VPWR VPWR sky130_fd_sc_hd__decap_3
XFILLER_95_306 VGND VGND VPWR VPWR sky130_fd_sc_hd__decap_3
XTAP_TAPCELL_ROW_8_351 VGND VPWR sky130_fd_sc_hd__tapvpwrvgnd_1
XFILLER_110_628 VGND VGND VPWR VPWR sky130_fd_sc_hd__decap_3
XFILLER_48_200 VGND VGND VPWR VPWR sky130_fd_sc_hd__decap_3
XFILLER_0_284 VGND VGND VPWR VPWR sky130_fd_sc_hd__decap_3
XFILLER_48_222 VGND VGND VPWR VPWR sky130_fd_sc_hd__decap_3
XFILLER_76_542 VGND VGND VPWR VPWR sky130_fd_sc_hd__decap_3
XFILLER_88_380 VGND VGND VPWR VPWR sky130_fd_sc_hd__decap_3
XFILLER_76_575 VGND VGND VPWR VPWR sky130_fd_sc_hd__decap_3
XFILLER_17_620 VGND VGND VPWR VPWR sky130_fd_sc_hd__decap_3
XFILLER_63_225 VGND VGND VPWR VPWR sky130_fd_sc_hd__decap_3
XFILLER_91_534 VGND VGND VPWR VPWR sky130_fd_sc_hd__decap_3
XTAP_TAPCELL_ROW_106_1521 VGND VPWR sky130_fd_sc_hd__tapvpwrvgnd_1
XFILLER_16_141 VGND VGND VPWR VPWR sky130_fd_sc_hd__fill_2
XFILLER_17_653 VGND VGND VPWR VPWR sky130_fd_sc_hd__decap_3
XFILLER_51_409 VGND VGND VPWR VPWR sky130_fd_sc_hd__decap_3
XFILLER_63_258 VGND VGND VPWR VPWR sky130_fd_sc_hd__decap_3
XFILLER_91_567 VGND VGND VPWR VPWR sky130_fd_sc_hd__decap_3
XFILLER_32_601 VGND VGND VPWR VPWR sky130_fd_sc_hd__decap_3
Xplace269 _3629_/A VGND VGND VPWR VPWR _3682_/A sky130_fd_sc_hd__buf_2
XFILLER_32_634 VGND VGND VPWR VPWR sky130_fd_sc_hd__decap_3
XFILLER_32_645 VGND VGND VPWR VPWR sky130_fd_sc_hd__decap_3
XFILLER_31_144 VGND VGND VPWR VPWR sky130_fd_sc_hd__decap_3
XFILLER_31_177 VGND VGND VPWR VPWR sky130_fd_sc_hd__decap_3
XFILLER_32_678 VGND VGND VPWR VPWR sky130_fd_sc_hd__decap_3
X_3790_ _3746_/X _3777_/X _3779_/X _3629_/A _3789_/X VGND VGND VPWR VPWR _3790_/X
+ sky130_fd_sc_hd__a221o_2
XFILLER_8_340 VGND VGND VPWR VPWR sky130_fd_sc_hd__fill_1
XFILLER_8_362 VGND VGND VPWR VPWR sky130_fd_sc_hd__fill_2
XFILLER_68_3 VGND VGND VPWR VPWR sky130_fd_sc_hd__decap_3
XFILLER_8_384 VGND VGND VPWR VPWR sky130_fd_sc_hd__decap_3
X_4411_ _4411_/A _4411_/B VGND VGND VPWR VPWR _4412_/B sky130_fd_sc_hd__and2_2
XFILLER_99_612 VGND VGND VPWR VPWR sky130_fd_sc_hd__decap_3
XFILLER_113_411 VGND VGND VPWR VPWR sky130_fd_sc_hd__decap_3
X_7130_ _7353_/CLK _7130_/D _6410_/Y VGND VGND VPWR VPWR _7130_/Q sky130_fd_sc_hd__dfrtp_2
X_4342_ _7063_/Q _4305_/B _4460_/A VGND VGND VPWR VPWR _4365_/B sky130_fd_sc_hd__o21a_2
XFILLER_99_623 VGND VGND VPWR VPWR sky130_fd_sc_hd__decap_3
XFILLER_98_100 VGND VGND VPWR VPWR sky130_fd_sc_hd__decap_3
XFILLER_101_606 VGND VGND VPWR VPWR sky130_fd_sc_hd__decap_3
XFILLER_113_444 VGND VGND VPWR VPWR sky130_fd_sc_hd__decap_3
XFILLER_113_455 VGND VGND VPWR VPWR sky130_fd_sc_hd__decap_3
X_7061_ _7311_/CLK _7061_/D _6341_/Y VGND VGND VPWR VPWR _7061_/Q sky130_fd_sc_hd__dfrtp_2
X_4273_ _4376_/A _4376_/B _4376_/C _4273_/D VGND VGND VPWR VPWR _4275_/A sky130_fd_sc_hd__nor4_2
XFILLER_99_656 VGND VGND VPWR VPWR sky130_fd_sc_hd__decap_3
XFILLER_101_617 VGND VGND VPWR VPWR sky130_fd_sc_hd__decap_3
XFILLER_113_488 VGND VGND VPWR VPWR sky130_fd_sc_hd__decap_3
XFILLER_86_306 VGND VGND VPWR VPWR sky130_fd_sc_hd__fill_2
XFILLER_86_328 VGND VGND VPWR VPWR sky130_fd_sc_hd__fill_2
.ends
