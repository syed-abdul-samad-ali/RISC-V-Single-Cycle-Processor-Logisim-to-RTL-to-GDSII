* NGSPICE file created from single_cycle_cpu.ext - technology: sky130A

* Black-box entry subcircuit for sky130_fd_sc_hd__fill_1 abstract view
.subckt sky130_fd_sc_hd__fill_1 VGND VNB VPB VPWR
.ends

* Black-box entry subcircuit for sky130_fd_sc_hd__fill_2 abstract view
.subckt sky130_fd_sc_hd__fill_2 VGND VNB VPB VPWR
.ends

* Black-box entry subcircuit for sky130_fd_sc_hd__decap_3 abstract view
.subckt sky130_fd_sc_hd__decap_3 VGND VNB VPB VPWR
.ends

* Black-box entry subcircuit for sky130_fd_sc_hd__dfxtp_2 abstract view
.subckt sky130_fd_sc_hd__dfxtp_2 CLK D VGND VNB VPB VPWR Q
.ends

* Black-box entry subcircuit for sky130_fd_sc_hd__tapvpwrvgnd_1 abstract view
.subckt sky130_fd_sc_hd__tapvpwrvgnd_1 VGND VPWR
.ends

* Black-box entry subcircuit for sky130_fd_sc_hd__mux2_2 abstract view
.subckt sky130_fd_sc_hd__mux2_2 A0 A1 S VGND VNB VPB VPWR X
.ends

* Black-box entry subcircuit for sky130_fd_sc_hd__nor4_2 abstract view
.subckt sky130_fd_sc_hd__nor4_2 A B C D VGND VNB VPB VPWR Y
.ends

* Black-box entry subcircuit for sky130_fd_sc_hd__or2_2 abstract view
.subckt sky130_fd_sc_hd__or2_2 A B VGND VNB VPB VPWR X
.ends

* Black-box entry subcircuit for sky130_fd_sc_hd__dfrtp_2 abstract view
.subckt sky130_fd_sc_hd__dfrtp_2 CLK D RESET_B VGND VNB VPB VPWR Q
.ends

* Black-box entry subcircuit for sky130_fd_sc_hd__dlygate4sd3_1 abstract view
.subckt sky130_fd_sc_hd__dlygate4sd3_1 A VGND VNB VPB VPWR X
.ends

* Black-box entry subcircuit for sky130_fd_sc_hd__nor3_2 abstract view
.subckt sky130_fd_sc_hd__nor3_2 A B C VGND VNB VPB VPWR Y
.ends

* Black-box entry subcircuit for sky130_fd_sc_hd__a221o_2 abstract view
.subckt sky130_fd_sc_hd__a221o_2 A1 A2 B1 B2 C1 VGND VNB VPB VPWR X
.ends

* Black-box entry subcircuit for sky130_fd_sc_hd__inv_2 abstract view
.subckt sky130_fd_sc_hd__inv_2 A VGND VNB VPB VPWR Y
.ends

* Black-box entry subcircuit for sky130_fd_sc_hd__a22o_2 abstract view
.subckt sky130_fd_sc_hd__a22o_2 A1 A2 B1 B2 VGND VNB VPB VPWR X
.ends

* Black-box entry subcircuit for sky130_fd_sc_hd__clkdlybuf4s25_1 abstract view
.subckt sky130_fd_sc_hd__clkdlybuf4s25_1 A VGND VNB VPB VPWR X
.ends

* Black-box entry subcircuit for sky130_fd_sc_hd__a211o_2 abstract view
.subckt sky130_fd_sc_hd__a211o_2 A1 A2 B1 C1 VGND VNB VPB VPWR X
.ends

* Black-box entry subcircuit for sky130_fd_sc_hd__and3_4 abstract view
.subckt sky130_fd_sc_hd__and3_4 A B C VGND VNB VPB VPWR X
.ends

* Black-box entry subcircuit for sky130_fd_sc_hd__or4_4 abstract view
.subckt sky130_fd_sc_hd__or4_4 A B C D VGND VNB VPB VPWR X
.ends

* Black-box entry subcircuit for sky130_fd_sc_hd__a31o_2 abstract view
.subckt sky130_fd_sc_hd__a31o_2 A1 A2 A3 B1 VGND VNB VPB VPWR X
.ends

* Black-box entry subcircuit for sky130_fd_sc_hd__nor2_2 abstract view
.subckt sky130_fd_sc_hd__nor2_2 A B VGND VNB VPB VPWR Y
.ends

* Black-box entry subcircuit for sky130_fd_sc_hd__o31a_2 abstract view
.subckt sky130_fd_sc_hd__o31a_2 A1 A2 A3 B1 VGND VNB VPB VPWR X
.ends

* Black-box entry subcircuit for sky130_fd_sc_hd__conb_1 abstract view
.subckt sky130_fd_sc_hd__conb_1 VGND VNB VPB VPWR HI LO
.ends

* Black-box entry subcircuit for sky130_fd_sc_hd__or3b_4 abstract view
.subckt sky130_fd_sc_hd__or3b_4 A B C_N VGND VNB VPB VPWR X
.ends

* Black-box entry subcircuit for sky130_fd_sc_hd__and2_2 abstract view
.subckt sky130_fd_sc_hd__and2_2 A B VGND VNB VPB VPWR X
.ends

* Black-box entry subcircuit for sky130_fd_sc_hd__xnor2_2 abstract view
.subckt sky130_fd_sc_hd__xnor2_2 A B VGND VNB VPB VPWR Y
.ends

* Black-box entry subcircuit for sky130_fd_sc_hd__o21ai_2 abstract view
.subckt sky130_fd_sc_hd__o21ai_2 A1 A2 B1 VGND VNB VPB VPWR Y
.ends

* Black-box entry subcircuit for sky130_fd_sc_hd__nand2_2 abstract view
.subckt sky130_fd_sc_hd__nand2_2 A B VGND VNB VPB VPWR Y
.ends

* Black-box entry subcircuit for sky130_fd_sc_hd__and3_2 abstract view
.subckt sky130_fd_sc_hd__and3_2 A B C VGND VNB VPB VPWR X
.ends

* Black-box entry subcircuit for sky130_fd_sc_hd__and2b_2 abstract view
.subckt sky130_fd_sc_hd__and2b_2 A_N B VGND VNB VPB VPWR X
.ends

* Black-box entry subcircuit for sky130_fd_sc_hd__a21o_2 abstract view
.subckt sky130_fd_sc_hd__a21o_2 A1 A2 B1 VGND VNB VPB VPWR X
.ends

* Black-box entry subcircuit for sky130_fd_sc_hd__or3_2 abstract view
.subckt sky130_fd_sc_hd__or3_2 A B C VGND VNB VPB VPWR X
.ends

* Black-box entry subcircuit for sky130_fd_sc_hd__buf_2 abstract view
.subckt sky130_fd_sc_hd__buf_2 A VGND VNB VPB VPWR X
.ends

* Black-box entry subcircuit for sky130_fd_sc_hd__diode_2 abstract view
.subckt sky130_fd_sc_hd__diode_2 DIODE VGND VNB VPB VPWR
.ends

* Black-box entry subcircuit for sky130_fd_sc_hd__a31oi_4 abstract view
.subckt sky130_fd_sc_hd__a31oi_4 A1 A2 A3 B1 VGND VNB VPB VPWR Y
.ends

* Black-box entry subcircuit for sky130_fd_sc_hd__o21a_2 abstract view
.subckt sky130_fd_sc_hd__o21a_2 A1 A2 B1 VGND VNB VPB VPWR X
.ends

* Black-box entry subcircuit for sky130_fd_sc_hd__o32a_2 abstract view
.subckt sky130_fd_sc_hd__o32a_2 A1 A2 A3 B1 B2 VGND VNB VPB VPWR X
.ends

* Black-box entry subcircuit for sky130_fd_sc_hd__or3b_2 abstract view
.subckt sky130_fd_sc_hd__or3b_2 A B C_N VGND VNB VPB VPWR X
.ends

* Black-box entry subcircuit for sky130_fd_sc_hd__clkbuf_16 abstract view
.subckt sky130_fd_sc_hd__clkbuf_16 A VGND VNB VPB VPWR X
.ends

* Black-box entry subcircuit for sky130_fd_sc_hd__o211ai_2 abstract view
.subckt sky130_fd_sc_hd__o211ai_2 A1 A2 B1 C1 VGND VNB VPB VPWR Y
.ends

* Black-box entry subcircuit for sky130_fd_sc_hd__o22a_2 abstract view
.subckt sky130_fd_sc_hd__o22a_2 A1 A2 B1 B2 VGND VNB VPB VPWR X
.ends

* Black-box entry subcircuit for sky130_fd_sc_hd__o221a_2 abstract view
.subckt sky130_fd_sc_hd__o221a_2 A1 A2 B1 B2 C1 VGND VNB VPB VPWR X
.ends

* Black-box entry subcircuit for sky130_fd_sc_hd__o311a_4 abstract view
.subckt sky130_fd_sc_hd__o311a_4 A1 A2 A3 B1 C1 VGND VNB VPB VPWR X
.ends

* Black-box entry subcircuit for sky130_fd_sc_hd__a211oi_4 abstract view
.subckt sky130_fd_sc_hd__a211oi_4 A1 A2 B1 C1 VGND VNB VPB VPWR Y
.ends

* Black-box entry subcircuit for sky130_fd_sc_hd__xor2_2 abstract view
.subckt sky130_fd_sc_hd__xor2_2 A B VGND VNB VPB VPWR X
.ends

* Black-box entry subcircuit for sky130_fd_sc_hd__or4b_2 abstract view
.subckt sky130_fd_sc_hd__or4b_2 A B C D_N VGND VNB VPB VPWR X
.ends

* Black-box entry subcircuit for sky130_fd_sc_hd__o2bb2a_2 abstract view
.subckt sky130_fd_sc_hd__o2bb2a_2 A1_N A2_N B1 B2 VGND VNB VPB VPWR X
.ends

* Black-box entry subcircuit for sky130_fd_sc_hd__nand3_2 abstract view
.subckt sky130_fd_sc_hd__nand3_2 A B C VGND VNB VPB VPWR Y
.ends

* Black-box entry subcircuit for sky130_fd_sc_hd__o31ai_4 abstract view
.subckt sky130_fd_sc_hd__o31ai_4 A1 A2 A3 B1 VGND VNB VPB VPWR Y
.ends

* Black-box entry subcircuit for sky130_fd_sc_hd__o21ba_2 abstract view
.subckt sky130_fd_sc_hd__o21ba_2 A1 A2 B1_N VGND VNB VPB VPWR X
.ends

* Black-box entry subcircuit for sky130_fd_sc_hd__or2_4 abstract view
.subckt sky130_fd_sc_hd__or2_4 A B VGND VNB VPB VPWR X
.ends

* Black-box entry subcircuit for sky130_fd_sc_hd__a211oi_2 abstract view
.subckt sky130_fd_sc_hd__a211oi_2 A1 A2 B1 C1 VGND VNB VPB VPWR Y
.ends

* Black-box entry subcircuit for sky130_fd_sc_hd__a21bo_2 abstract view
.subckt sky130_fd_sc_hd__a21bo_2 A1 A2 B1_N VGND VNB VPB VPWR X
.ends

* Black-box entry subcircuit for sky130_fd_sc_hd__a31oi_2 abstract view
.subckt sky130_fd_sc_hd__a31oi_2 A1 A2 A3 B1 VGND VNB VPB VPWR Y
.ends

* Black-box entry subcircuit for sky130_fd_sc_hd__a21oi_2 abstract view
.subckt sky130_fd_sc_hd__a21oi_2 A1 A2 B1 VGND VNB VPB VPWR Y
.ends

* Black-box entry subcircuit for sky130_fd_sc_hd__o211a_2 abstract view
.subckt sky130_fd_sc_hd__o211a_2 A1 A2 B1 C1 VGND VNB VPB VPWR X
.ends

* Black-box entry subcircuit for sky130_fd_sc_hd__or2b_2 abstract view
.subckt sky130_fd_sc_hd__or2b_2 A B_N VGND VNB VPB VPWR X
.ends

* Black-box entry subcircuit for sky130_fd_sc_hd__a32o_2 abstract view
.subckt sky130_fd_sc_hd__a32o_2 A1 A2 A3 B1 B2 VGND VNB VPB VPWR X
.ends

* Black-box entry subcircuit for sky130_fd_sc_hd__a2bb2o_2 abstract view
.subckt sky130_fd_sc_hd__a2bb2o_2 A1_N A2_N B1 B2 VGND VNB VPB VPWR X
.ends

* Black-box entry subcircuit for sky130_fd_sc_hd__xor2_4 abstract view
.subckt sky130_fd_sc_hd__xor2_4 A B VGND VNB VPB VPWR X
.ends

* Black-box entry subcircuit for sky130_fd_sc_hd__a21boi_2 abstract view
.subckt sky130_fd_sc_hd__a21boi_2 A1 A2 B1_N VGND VNB VPB VPWR Y
.ends

* Black-box entry subcircuit for sky130_fd_sc_hd__and2_4 abstract view
.subckt sky130_fd_sc_hd__and2_4 A B VGND VNB VPB VPWR X
.ends

* Black-box entry subcircuit for sky130_fd_sc_hd__o2111a_2 abstract view
.subckt sky130_fd_sc_hd__o2111a_2 A1 A2 B1 C1 D1 VGND VNB VPB VPWR X
.ends

* Black-box entry subcircuit for sky130_fd_sc_hd__and4_4 abstract view
.subckt sky130_fd_sc_hd__and4_4 A B C D VGND VNB VPB VPWR X
.ends

* Black-box entry subcircuit for sky130_fd_sc_hd__o31ai_2 abstract view
.subckt sky130_fd_sc_hd__o31ai_2 A1 A2 A3 B1 VGND VNB VPB VPWR Y
.ends

* Black-box entry subcircuit for sky130_fd_sc_hd__buf_1 abstract view
.subckt sky130_fd_sc_hd__buf_1 A VGND VNB VPB VPWR X
.ends

* Black-box entry subcircuit for sky130_fd_sc_hd__o311a_2 abstract view
.subckt sky130_fd_sc_hd__o311a_2 A1 A2 A3 B1 C1 VGND VNB VPB VPWR X
.ends

* Black-box entry subcircuit for sky130_fd_sc_hd__clkinv_4 abstract view
.subckt sky130_fd_sc_hd__clkinv_4 A VGND VNB VPB VPWR Y
.ends

* Black-box entry subcircuit for sky130_fd_sc_hd__a31o_4 abstract view
.subckt sky130_fd_sc_hd__a31o_4 A1 A2 A3 B1 VGND VNB VPB VPWR X
.ends

* Black-box entry subcircuit for sky130_fd_sc_hd__inv_4 abstract view
.subckt sky130_fd_sc_hd__inv_4 A VGND VNB VPB VPWR Y
.ends

* Black-box entry subcircuit for sky130_fd_sc_hd__bufinv_16 abstract view
.subckt sky130_fd_sc_hd__bufinv_16 A VGND VNB VPB VPWR Y
.ends

* Black-box entry subcircuit for sky130_fd_sc_hd__nor2_4 abstract view
.subckt sky130_fd_sc_hd__nor2_4 A B VGND VNB VPB VPWR Y
.ends

* Black-box entry subcircuit for sky130_fd_sc_hd__clkinv_2 abstract view
.subckt sky130_fd_sc_hd__clkinv_2 A VGND VNB VPB VPWR Y
.ends

* Black-box entry subcircuit for sky130_fd_sc_hd__clkbuf_1 abstract view
.subckt sky130_fd_sc_hd__clkbuf_1 A VGND VNB VPB VPWR X
.ends

* Black-box entry subcircuit for sky130_fd_sc_hd__a221oi_2 abstract view
.subckt sky130_fd_sc_hd__a221oi_2 A1 A2 B1 B2 C1 VGND VNB VPB VPWR Y
.ends

* Black-box entry subcircuit for sky130_fd_sc_hd__and3b_2 abstract view
.subckt sky130_fd_sc_hd__and3b_2 A_N B C VGND VNB VPB VPWR X
.ends

* Black-box entry subcircuit for sky130_fd_sc_hd__nand3b_2 abstract view
.subckt sky130_fd_sc_hd__nand3b_2 A_N B C VGND VNB VPB VPWR Y
.ends

* Black-box entry subcircuit for sky130_fd_sc_hd__clkbuf_8 abstract view
.subckt sky130_fd_sc_hd__clkbuf_8 A VGND VNB VPB VPWR X
.ends

* Black-box entry subcircuit for sky130_fd_sc_hd__clkbuf_2 abstract view
.subckt sky130_fd_sc_hd__clkbuf_2 A VGND VNB VPB VPWR X
.ends

* Black-box entry subcircuit for sky130_fd_sc_hd__or3_4 abstract view
.subckt sky130_fd_sc_hd__or3_4 A B C VGND VNB VPB VPWR X
.ends

* Black-box entry subcircuit for sky130_fd_sc_hd__nor4b_2 abstract view
.subckt sky130_fd_sc_hd__nor4b_2 A B C D_N VGND VNB VPB VPWR Y
.ends

* Black-box entry subcircuit for sky130_fd_sc_hd__inv_6 abstract view
.subckt sky130_fd_sc_hd__inv_6 A VGND VNB VPB VPWR Y
.ends

* Black-box entry subcircuit for sky130_fd_sc_hd__a21oi_4 abstract view
.subckt sky130_fd_sc_hd__a21oi_4 A1 A2 B1 VGND VNB VPB VPWR Y
.ends

* Black-box entry subcircuit for sky130_fd_sc_hd__o221ai_2 abstract view
.subckt sky130_fd_sc_hd__o221ai_2 A1 A2 B1 B2 C1 VGND VNB VPB VPWR Y
.ends

* Black-box entry subcircuit for sky130_fd_sc_hd__nand2b_4 abstract view
.subckt sky130_fd_sc_hd__nand2b_4 A_N B VGND VNB VPB VPWR Y
.ends

* Black-box entry subcircuit for sky130_fd_sc_hd__a2111o_2 abstract view
.subckt sky130_fd_sc_hd__a2111o_2 A1 A2 B1 C1 D1 VGND VNB VPB VPWR X
.ends

* Black-box entry subcircuit for sky130_fd_sc_hd__inv_12 abstract view
.subckt sky130_fd_sc_hd__inv_12 A VGND VNB VPB VPWR Y
.ends

* Black-box entry subcircuit for sky130_fd_sc_hd__mux4_2 abstract view
.subckt sky130_fd_sc_hd__mux4_2 A0 A1 A2 A3 S0 S1 VGND VNB VPB VPWR X
.ends

* Black-box entry subcircuit for sky130_fd_sc_hd__dfstp_2 abstract view
.subckt sky130_fd_sc_hd__dfstp_2 CLK D SET_B VGND VNB VPB VPWR Q
.ends

* Black-box entry subcircuit for sky130_fd_sc_hd__nor2b_2 abstract view
.subckt sky130_fd_sc_hd__nor2b_2 A B_N VGND VNB VPB VPWR Y
.ends

* Black-box entry subcircuit for sky130_fd_sc_hd__or4_2 abstract view
.subckt sky130_fd_sc_hd__or4_2 A B C D VGND VNB VPB VPWR X
.ends

* Black-box entry subcircuit for sky130_fd_sc_hd__and4_2 abstract view
.subckt sky130_fd_sc_hd__and4_2 A B C D VGND VNB VPB VPWR X
.ends

* Black-box entry subcircuit for sky130_fd_sc_hd__a311oi_2 abstract view
.subckt sky130_fd_sc_hd__a311oi_2 A1 A2 A3 B1 C1 VGND VNB VPB VPWR Y
.ends

* Black-box entry subcircuit for sky130_fd_sc_hd__o21a_4 abstract view
.subckt sky130_fd_sc_hd__o21a_4 A1 A2 B1 VGND VNB VPB VPWR X
.ends

* Black-box entry subcircuit for sky130_fd_sc_hd__a41o_2 abstract view
.subckt sky130_fd_sc_hd__a41o_2 A1 A2 A3 A4 B1 VGND VNB VPB VPWR X
.ends

* Black-box entry subcircuit for sky130_fd_sc_hd__buf_4 abstract view
.subckt sky130_fd_sc_hd__buf_4 A VGND VNB VPB VPWR X
.ends

* Black-box entry subcircuit for sky130_fd_sc_hd__nand4bb_2 abstract view
.subckt sky130_fd_sc_hd__nand4bb_2 A_N B_N C D VGND VNB VPB VPWR Y
.ends

* Black-box entry subcircuit for sky130_fd_sc_hd__o21bai_2 abstract view
.subckt sky130_fd_sc_hd__o21bai_2 A1 A2 B1_N VGND VNB VPB VPWR Y
.ends

* Black-box entry subcircuit for sky130_fd_sc_hd__nand2_4 abstract view
.subckt sky130_fd_sc_hd__nand2_4 A B VGND VNB VPB VPWR Y
.ends

* Black-box entry subcircuit for sky130_fd_sc_hd__mux2_4 abstract view
.subckt sky130_fd_sc_hd__mux2_4 A0 A1 S VGND VNB VPB VPWR X
.ends

* Black-box entry subcircuit for sky130_fd_sc_hd__o211ai_4 abstract view
.subckt sky130_fd_sc_hd__o211ai_4 A1 A2 B1 C1 VGND VNB VPB VPWR Y
.ends

* Black-box entry subcircuit for sky130_fd_sc_hd__and4bb_4 abstract view
.subckt sky130_fd_sc_hd__and4bb_4 A_N B_N C D VGND VNB VPB VPWR X
.ends

* Black-box entry subcircuit for sky130_fd_sc_hd__nand2b_2 abstract view
.subckt sky130_fd_sc_hd__nand2b_2 A_N B VGND VNB VPB VPWR Y
.ends

* Black-box entry subcircuit for sky130_fd_sc_hd__o211a_4 abstract view
.subckt sky130_fd_sc_hd__o211a_4 A1 A2 B1 C1 VGND VNB VPB VPWR X
.ends

* Black-box entry subcircuit for sky130_fd_sc_hd__or4b_4 abstract view
.subckt sky130_fd_sc_hd__or4b_4 A B C D_N VGND VNB VPB VPWR X
.ends

* Black-box entry subcircuit for sky130_fd_sc_hd__nor4bb_2 abstract view
.subckt sky130_fd_sc_hd__nor4bb_2 A B C_N D_N VGND VNB VPB VPWR Y
.ends

* Black-box entry subcircuit for sky130_fd_sc_hd__and4b_4 abstract view
.subckt sky130_fd_sc_hd__and4b_4 A_N B C D VGND VNB VPB VPWR X
.ends

* Black-box entry subcircuit for sky130_fd_sc_hd__nor3b_2 abstract view
.subckt sky130_fd_sc_hd__nor3b_2 A B C_N VGND VNB VPB VPWR Y
.ends

* Black-box entry subcircuit for sky130_fd_sc_hd__a22oi_2 abstract view
.subckt sky130_fd_sc_hd__a22oi_2 A1 A2 B1 B2 VGND VNB VPB VPWR Y
.ends

* Black-box entry subcircuit for sky130_fd_sc_hd__a311o_2 abstract view
.subckt sky130_fd_sc_hd__a311o_2 A1 A2 A3 B1 C1 VGND VNB VPB VPWR X
.ends

* Black-box entry subcircuit for sky130_fd_sc_hd__clkbuf_4 abstract view
.subckt sky130_fd_sc_hd__clkbuf_4 A VGND VNB VPB VPWR X
.ends

* Black-box entry subcircuit for sky130_fd_sc_hd__nand4b_4 abstract view
.subckt sky130_fd_sc_hd__nand4b_4 A_N B C D VGND VNB VPB VPWR Y
.ends

* Black-box entry subcircuit for sky130_fd_sc_hd__a2bb2o_4 abstract view
.subckt sky130_fd_sc_hd__a2bb2o_4 A1_N A2_N B1 B2 VGND VNB VPB VPWR X
.ends

* Black-box entry subcircuit for sky130_fd_sc_hd__nor4_1 abstract view
.subckt sky130_fd_sc_hd__nor4_1 A B C D VGND VNB VPB VPWR Y
.ends

.subckt single_cycle_cpu VGND VPWR alu_result_out[0] alu_result_out[10] alu_result_out[11]
+ alu_result_out[12] alu_result_out[13] alu_result_out[14] alu_result_out[15] alu_result_out[16]
+ alu_result_out[17] alu_result_out[18] alu_result_out[19] alu_result_out[1] alu_result_out[20]
+ alu_result_out[21] alu_result_out[22] alu_result_out[23] alu_result_out[24] alu_result_out[25]
+ alu_result_out[26] alu_result_out[27] alu_result_out[28] alu_result_out[29] alu_result_out[2]
+ alu_result_out[30] alu_result_out[31] alu_result_out[3] alu_result_out[4] alu_result_out[5]
+ alu_result_out[6] alu_result_out[7] alu_result_out[8] alu_result_out[9] clk instruction_out[0]
+ instruction_out[10] instruction_out[11] instruction_out[12] instruction_out[13]
+ instruction_out[14] instruction_out[15] instruction_out[16] instruction_out[17]
+ instruction_out[18] instruction_out[19] instruction_out[1] instruction_out[20] instruction_out[21]
+ instruction_out[22] instruction_out[23] instruction_out[24] instruction_out[25]
+ instruction_out[26] instruction_out[27] instruction_out[28] instruction_out[29]
+ instruction_out[2] instruction_out[30] instruction_out[31] instruction_out[3] instruction_out[4]
+ instruction_out[5] instruction_out[6] instruction_out[7] instruction_out[8] instruction_out[9]
+ pc_out[0] pc_out[10] pc_out[11] pc_out[12] pc_out[13] pc_out[14] pc_out[15] pc_out[16]
+ pc_out[17] pc_out[18] pc_out[19] pc_out[1] pc_out[20] pc_out[21] pc_out[22] pc_out[23]
+ pc_out[24] pc_out[25] pc_out[26] pc_out[27] pc_out[28] pc_out[29] pc_out[2] pc_out[30]
+ pc_out[31] pc_out[3] pc_out[4] pc_out[5] pc_out[6] pc_out[7] pc_out[8] pc_out[9]
+ reset
XFILLER_79_391 VGND VGND VPWR VPWR sky130_fd_sc_hd__fill_1
XFILLER_100_138 VGND VGND VPWR VPWR sky130_fd_sc_hd__fill_2
XFILLER_67_553 VGND VGND VPWR VPWR sky130_fd_sc_hd__decap_3
XFILLER_39_255 VGND VGND VPWR VPWR sky130_fd_sc_hd__decap_3
XFILLER_55_715 VGND VGND VPWR VPWR sky130_fd_sc_hd__decap_3
XFILLER_67_597 VGND VGND VPWR VPWR sky130_fd_sc_hd__decap_3
XFILLER_54_214 VGND VGND VPWR VPWR sky130_fd_sc_hd__decap_3
XFILLER_70_707 VGND VGND VPWR VPWR sky130_fd_sc_hd__decap_3
X_6914_ _7378_/CLK _6914_/D VGND VGND VPWR VPWR _6914_/Q sky130_fd_sc_hd__dfxtp_2
XFILLER_82_589 VGND VGND VPWR VPWR sky130_fd_sc_hd__decap_3
XFILLER_23_601 VGND VGND VPWR VPWR sky130_fd_sc_hd__decap_3
XTAP_TAPCELL_ROW_85_1373 VGND VPWR sky130_fd_sc_hd__tapvpwrvgnd_1
XFILLER_23_623 VGND VGND VPWR VPWR sky130_fd_sc_hd__decap_3
X_6845_ clkload6/A _6845_/D VGND VGND VPWR VPWR _6845_/Q sky130_fd_sc_hd__dfxtp_2
XFILLER_35_494 VGND VGND VPWR VPWR sky130_fd_sc_hd__fill_1
XFILLER_22_122 VGND VGND VPWR VPWR sky130_fd_sc_hd__fill_1
XFILLER_52_29 VGND VGND VPWR VPWR sky130_fd_sc_hd__decap_3
XFILLER_23_656 VGND VGND VPWR VPWR sky130_fd_sc_hd__decap_3
XFILLER_50_442 VGND VGND VPWR VPWR sky130_fd_sc_hd__decap_3
X_6776_ _6960_/CLK _6776_/D VGND VGND VPWR VPWR _6776_/Q sky130_fd_sc_hd__dfxtp_2
XFILLER_50_475 VGND VGND VPWR VPWR sky130_fd_sc_hd__fill_1
XFILLER_10_317 VGND VGND VPWR VPWR sky130_fd_sc_hd__fill_2
XFILLER_50_486 VGND VGND VPWR VPWR sky130_fd_sc_hd__decap_3
XTAP_TAPCELL_ROW_33_695 VGND VPWR sky130_fd_sc_hd__tapvpwrvgnd_1
X_5727_ _7369_/Q hold918/X _5735_/S VGND VGND VPWR VPWR _6713_/D sky130_fd_sc_hd__mux2_2
XFILLER_109_706 VGND VGND VPWR VPWR sky130_fd_sc_hd__decap_3
XFILLER_108_205 VGND VGND VPWR VPWR sky130_fd_sc_hd__decap_3
X_5658_ _5658_/A _5658_/B _5658_/C _5658_/D VGND VGND VPWR VPWR _5661_/C sky130_fd_sc_hd__nor4_2
X_5589_ _5589_/A _5595_/B VGND VGND VPWR VPWR _7033_/D sky130_fd_sc_hd__or2_2
XFILLER_2_516 VGND VGND VPWR VPWR sky130_fd_sc_hd__decap_3
X_7328_ _7359_/CLK _7328_/D _6608_/Y VGND VGND VPWR VPWR _7328_/Q sky130_fd_sc_hd__dfrtp_2
XFILLER_89_100 VGND VGND VPWR VPWR sky130_fd_sc_hd__decap_3
XFILLER_117_33 VGND VGND VPWR VPWR sky130_fd_sc_hd__decap_3
XFILLER_89_133 VGND VGND VPWR VPWR sky130_fd_sc_hd__decap_3
XFILLER_77_15 VGND VGND VPWR VPWR sky130_fd_sc_hd__decap_3
XFILLER_117_66 VGND VGND VPWR VPWR sky130_fd_sc_hd__decap_3
X_7259_ _7325_/CLK _7259_/D _6539_/Y VGND VGND VPWR VPWR _7259_/Q sky130_fd_sc_hd__dfrtp_2
XFILLER_77_317 VGND VGND VPWR VPWR sky130_fd_sc_hd__decap_3
XFILLER_117_99 VGND VGND VPWR VPWR sky130_fd_sc_hd__decap_3
XTAP_TAPCELL_ROW_5_332 VGND VPWR sky130_fd_sc_hd__tapvpwrvgnd_1
XFILLER_58_542 VGND VGND VPWR VPWR sky130_fd_sc_hd__fill_1
XFILLER_58_564 VGND VGND VPWR VPWR sky130_fd_sc_hd__decap_3
XFILLER_46_704 VGND VGND VPWR VPWR sky130_fd_sc_hd__decap_3
Xhold1040 _7207_/Q VGND VGND VPWR VPWR _5245_/A0 sky130_fd_sc_hd__dlygate4sd3_1
XFILLER_18_406 VGND VGND VPWR VPWR sky130_fd_sc_hd__decap_3
Xhold1051 _7336_/Q VGND VGND VPWR VPWR _4486_/A0 sky130_fd_sc_hd__dlygate4sd3_1
XFILLER_18_417 VGND VGND VPWR VPWR sky130_fd_sc_hd__decap_3
XFILLER_100_672 VGND VGND VPWR VPWR sky130_fd_sc_hd__decap_3
Xhold1062 _4474_/X VGND VGND VPWR VPWR _7342_/D sky130_fd_sc_hd__dlygate4sd3_1
XFILLER_93_36 VGND VGND VPWR VPWR sky130_fd_sc_hd__decap_3
XFILLER_85_383 VGND VGND VPWR VPWR sky130_fd_sc_hd__decap_3
XFILLER_45_214 VGND VGND VPWR VPWR sky130_fd_sc_hd__decap_3
Xhold1073 _7340_/Q VGND VGND VPWR VPWR _4478_/A0 sky130_fd_sc_hd__dlygate4sd3_1
XFILLER_45_225 VGND VGND VPWR VPWR sky130_fd_sc_hd__fill_2
XFILLER_18_439 VGND VGND VPWR VPWR sky130_fd_sc_hd__decap_3
Xhold1084 _7138_/Q VGND VGND VPWR VPWR _5390_/A0 sky130_fd_sc_hd__dlygate4sd3_1
Xhold1095 _7299_/Q VGND VGND VPWR VPWR _4563_/A sky130_fd_sc_hd__dlygate4sd3_1
XFILLER_45_247 VGND VGND VPWR VPWR sky130_fd_sc_hd__decap_3
XFILLER_61_718 VGND VGND VPWR VPWR sky130_fd_sc_hd__decap_3
XFILLER_61_729 VGND VGND VPWR VPWR sky130_fd_sc_hd__decap_3
XFILLER_60_206 VGND VGND VPWR VPWR sky130_fd_sc_hd__decap_3
XFILLER_14_601 VGND VGND VPWR VPWR sky130_fd_sc_hd__decap_3
XFILLER_26_483 VGND VGND VPWR VPWR sky130_fd_sc_hd__decap_3
XFILLER_26_85 VGND VGND VPWR VPWR sky130_fd_sc_hd__decap_3
XFILLER_14_634 VGND VGND VPWR VPWR sky130_fd_sc_hd__decap_3
XFILLER_14_645 VGND VGND VPWR VPWR sky130_fd_sc_hd__decap_3
XFILLER_41_431 VGND VGND VPWR VPWR sky130_fd_sc_hd__fill_1
XFILLER_13_133 VGND VGND VPWR VPWR sky130_fd_sc_hd__decap_3
XFILLER_14_678 VGND VGND VPWR VPWR sky130_fd_sc_hd__decap_3
XFILLER_41_497 VGND VGND VPWR VPWR sky130_fd_sc_hd__decap_3
XFILLER_9_148 VGND VGND VPWR VPWR sky130_fd_sc_hd__decap_3
XFILLER_5_321 VGND VGND VPWR VPWR sky130_fd_sc_hd__decap_3
XFILLER_115_709 VGND VGND VPWR VPWR sky130_fd_sc_hd__decap_3
XFILLER_5_343 VGND VGND VPWR VPWR sky130_fd_sc_hd__decap_3
XFILLER_96_604 VGND VGND VPWR VPWR sky130_fd_sc_hd__decap_3
XFILLER_3_23 VGND VGND VPWR VPWR sky130_fd_sc_hd__decap_3
XFILLER_96_637 VGND VGND VPWR VPWR sky130_fd_sc_hd__decap_3
XFILLER_96_648 VGND VGND VPWR VPWR sky130_fd_sc_hd__decap_3
XFILLER_1_582 VGND VGND VPWR VPWR sky130_fd_sc_hd__decap_3
XFILLER_110_447 VGND VGND VPWR VPWR sky130_fd_sc_hd__decap_3
XFILLER_95_147 VGND VGND VPWR VPWR sky130_fd_sc_hd__decap_3
XFILLER_37_715 VGND VGND VPWR VPWR sky130_fd_sc_hd__decap_3
XFILLER_64_501 VGND VGND VPWR VPWR sky130_fd_sc_hd__fill_2
XFILLER_36_203 VGND VGND VPWR VPWR sky130_fd_sc_hd__decap_3
XFILLER_52_707 VGND VGND VPWR VPWR sky130_fd_sc_hd__decap_3
X_4960_ _5587_/B _4960_/B _4960_/C VGND VGND VPWR VPWR _4961_/C sky130_fd_sc_hd__nor3_2
XFILLER_64_589 VGND VGND VPWR VPWR sky130_fd_sc_hd__decap_3
XFILLER_91_386 VGND VGND VPWR VPWR sky130_fd_sc_hd__decap_3
XFILLER_83_80 VGND VGND VPWR VPWR sky130_fd_sc_hd__decap_3
X_3911_ _6690_/Q _3925_/A2 _3925_/B1 _6868_/Q _3910_/X VGND VGND VPWR VPWR _3911_/X
+ sky130_fd_sc_hd__a221o_2
XTAP_TAPCELL_ROW_121_1838 VGND VPWR sky130_fd_sc_hd__tapvpwrvgnd_1
X_4891_ _4970_/A1 _4126_/A _4889_/Y _4811_/C _4890_/Y VGND VGND VPWR VPWR _4891_/X
+ sky130_fd_sc_hd__a221o_2
XTAP_TAPCELL_ROW_50_919 VGND VPWR sky130_fd_sc_hd__tapvpwrvgnd_1
X_6630_ _6630_/A VGND VGND VPWR VPWR _6630_/Y sky130_fd_sc_hd__inv_2
XFILLER_32_453 VGND VGND VPWR VPWR sky130_fd_sc_hd__fill_2
X_3842_ _6925_/Q _3851_/A2 _3651_/Y _6789_/Q VGND VGND VPWR VPWR _3842_/X sky130_fd_sc_hd__a22o_2
XFILLER_20_604 VGND VGND VPWR VPWR sky130_fd_sc_hd__decap_3
XFILLER_32_486 VGND VGND VPWR VPWR sky130_fd_sc_hd__decap_3
XFILLER_20_637 VGND VGND VPWR VPWR sky130_fd_sc_hd__decap_3
XFILLER_20_648 VGND VGND VPWR VPWR sky130_fd_sc_hd__decap_3
X_6561_ _6594_/A VGND VGND VPWR VPWR _6561_/Y sky130_fd_sc_hd__inv_2
X_3773_ _6775_/Q _3884_/A2 _3898_/B1 _6763_/Q VGND VGND VPWR VPWR _3773_/X sky130_fd_sc_hd__a22o_2
XTAP_TAPCELL_ROW_30_654 VGND VPWR sky130_fd_sc_hd__tapvpwrvgnd_1
XFILLER_9_671 VGND VGND VPWR VPWR sky130_fd_sc_hd__fill_1
XFILLER_9_682 VGND VGND VPWR VPWR sky130_fd_sc_hd__decap_3
XFILLER_118_525 VGND VGND VPWR VPWR sky130_fd_sc_hd__decap_3
X_6492_ _6556_/A VGND VGND VPWR VPWR _6492_/Y sky130_fd_sc_hd__inv_2
XFILLER_118_536 VGND VGND VPWR VPWR sky130_fd_sc_hd__decap_3
XFILLER_118_569 VGND VGND VPWR VPWR sky130_fd_sc_hd__decap_3
XFILLER_114_731 VGND VGND VPWR VPWR sky130_fd_sc_hd__decap_3
Xoutput467 _5657_/D VGND VGND VPWR VPWR alu_result_out[15] sky130_fd_sc_hd__clkdlybuf4s25_1
X_7113_ _7404_/CLK _7113_/D _6393_/Y VGND VGND VPWR VPWR _7113_/Q sky130_fd_sc_hd__dfrtp_2
X_4325_ _7354_/Q _4270_/B _4323_/X _4324_/X VGND VGND VPWR VPWR _4325_/X sky130_fd_sc_hd__a211o_2
Xoutput478 _5663_/B VGND VGND VPWR VPWR alu_result_out[25] sky130_fd_sc_hd__clkdlybuf4s25_1
Xoutput489 _3741_/B VGND VGND VPWR VPWR alu_result_out[6] sky130_fd_sc_hd__clkdlybuf4s25_1
XFILLER_87_615 VGND VGND VPWR VPWR sky130_fd_sc_hd__fill_1
XFILLER_87_626 VGND VGND VPWR VPWR sky130_fd_sc_hd__decap_3
XFILLER_86_114 VGND VGND VPWR VPWR sky130_fd_sc_hd__decap_3
X_7044_ _7362_/CLK _7044_/D _6324_/Y VGND VGND VPWR VPWR _7044_/Q sky130_fd_sc_hd__dfrtp_2
XFILLER_101_425 VGND VGND VPWR VPWR sky130_fd_sc_hd__decap_3
X_4256_ _4626_/B _4626_/C _4256_/C VGND VGND VPWR VPWR _4988_/A sky130_fd_sc_hd__and3_4
XFILLER_87_659 VGND VGND VPWR VPWR sky130_fd_sc_hd__decap_3
XFILLER_113_296 VGND VGND VPWR VPWR sky130_fd_sc_hd__decap_3
XFILLER_101_458 VGND VGND VPWR VPWR sky130_fd_sc_hd__decap_3
XFILLER_74_309 VGND VGND VPWR VPWR sky130_fd_sc_hd__decap_3
XFILLER_28_704 VGND VGND VPWR VPWR sky130_fd_sc_hd__decap_3
XTAP_TAPCELL_ROW_87_1402 VGND VPWR sky130_fd_sc_hd__tapvpwrvgnd_1
X_4187_ _7327_/Q _3964_/S _4505_/S _7295_/Q VGND VGND VPWR VPWR _4187_/X sky130_fd_sc_hd__a22o_2
XFILLER_55_501 VGND VGND VPWR VPWR sky130_fd_sc_hd__decap_3
XFILLER_27_203 VGND VGND VPWR VPWR sky130_fd_sc_hd__decap_3
XFILLER_27_225 VGND VGND VPWR VPWR sky130_fd_sc_hd__decap_3
XFILLER_55_567 VGND VGND VPWR VPWR sky130_fd_sc_hd__decap_3
XTAP_TAPCELL_ROW_38_765 VGND VPWR sky130_fd_sc_hd__tapvpwrvgnd_1
XFILLER_43_718 VGND VGND VPWR VPWR sky130_fd_sc_hd__decap_3
XFILLER_103_57 VGND VGND VPWR VPWR sky130_fd_sc_hd__decap_3
XFILLER_27_269 VGND VGND VPWR VPWR sky130_fd_sc_hd__decap_3
XFILLER_43_729 VGND VGND VPWR VPWR sky130_fd_sc_hd__decap_3
XFILLER_42_206 VGND VGND VPWR VPWR sky130_fd_sc_hd__decap_3
XFILLER_82_397 VGND VGND VPWR VPWR sky130_fd_sc_hd__decap_3
X_6828_ clkload8/A _6828_/D VGND VGND VPWR VPWR _6828_/Q sky130_fd_sc_hd__dfxtp_2
XFILLER_11_615 VGND VGND VPWR VPWR sky130_fd_sc_hd__fill_1
XFILLER_11_626 VGND VGND VPWR VPWR sky130_fd_sc_hd__decap_3
X_6759_ _6978_/CLK _6759_/D VGND VGND VPWR VPWR _6759_/Q sky130_fd_sc_hd__dfxtp_2
XFILLER_11_659 VGND VGND VPWR VPWR sky130_fd_sc_hd__decap_3
XTAP_TAPCELL_ROW_98_1542 VGND VPWR sky130_fd_sc_hd__tapvpwrvgnd_1
XFILLER_109_558 VGND VGND VPWR VPWR sky130_fd_sc_hd__fill_2
XFILLER_88_14 VGND VGND VPWR VPWR sky130_fd_sc_hd__fill_1
XFILLER_117_591 VGND VGND VPWR VPWR sky130_fd_sc_hd__decap_3
XFILLER_88_69 VGND VGND VPWR VPWR sky130_fd_sc_hd__decap_3
XFILLER_78_604 VGND VGND VPWR VPWR sky130_fd_sc_hd__decap_3
XFILLER_120_701 VGND VGND VPWR VPWR sky130_fd_sc_hd__decap_3
XFILLER_104_263 VGND VGND VPWR VPWR sky130_fd_sc_hd__decap_3
XFILLER_78_637 VGND VGND VPWR VPWR sky130_fd_sc_hd__decap_3
XFILLER_78_648 VGND VGND VPWR VPWR sky130_fd_sc_hd__decap_3
XFILLER_120_734 VGND VGND VPWR VPWR sky130_fd_sc_hd__fill_1
XFILLER_77_125 VGND VGND VPWR VPWR sky130_fd_sc_hd__decap_3
XFILLER_77_147 VGND VGND VPWR VPWR sky130_fd_sc_hd__decap_3
XFILLER_77_169 VGND VGND VPWR VPWR sky130_fd_sc_hd__decap_3
XFILLER_93_629 VGND VGND VPWR VPWR sky130_fd_sc_hd__decap_3
XFILLER_46_501 VGND VGND VPWR VPWR sky130_fd_sc_hd__decap_3
XFILLER_19_715 VGND VGND VPWR VPWR sky130_fd_sc_hd__decap_3
XFILLER_58_361 VGND VGND VPWR VPWR sky130_fd_sc_hd__decap_3
XFILLER_86_681 VGND VGND VPWR VPWR sky130_fd_sc_hd__decap_3
XFILLER_18_214 VGND VGND VPWR VPWR sky130_fd_sc_hd__fill_2
XFILLER_100_480 VGND VGND VPWR VPWR sky130_fd_sc_hd__decap_3
XFILLER_34_707 VGND VGND VPWR VPWR sky130_fd_sc_hd__decap_3
XFILLER_46_578 VGND VGND VPWR VPWR sky130_fd_sc_hd__decap_3
XFILLER_37_95 VGND VGND VPWR VPWR sky130_fd_sc_hd__fill_1
XFILLER_46_589 VGND VGND VPWR VPWR sky130_fd_sc_hd__fill_1
XTAP_TAPCELL_ROW_107_1660 VGND VPWR sky130_fd_sc_hd__tapvpwrvgnd_1
XFILLER_26_280 VGND VGND VPWR VPWR sky130_fd_sc_hd__decap_3
XFILLER_53_50 VGND VGND VPWR VPWR sky130_fd_sc_hd__decap_3
XFILLER_14_464 VGND VGND VPWR VPWR sky130_fd_sc_hd__decap_3
XFILLER_14_475 VGND VGND VPWR VPWR sky130_fd_sc_hd__fill_1
XFILLER_41_272 VGND VGND VPWR VPWR sky130_fd_sc_hd__decap_3
XFILLER_53_94 VGND VGND VPWR VPWR sky130_fd_sc_hd__decap_3
XFILLER_10_681 VGND VGND VPWR VPWR sky130_fd_sc_hd__decap_3
XTAP_TAPCELL_ROW_58_1025 VGND VPWR sky130_fd_sc_hd__tapvpwrvgnd_1
XFILLER_6_663 VGND VGND VPWR VPWR sky130_fd_sc_hd__decap_3
XFILLER_115_517 VGND VGND VPWR VPWR sky130_fd_sc_hd__decap_3
XFILLER_6_696 VGND VGND VPWR VPWR sky130_fd_sc_hd__decap_3
XFILLER_69_615 VGND VGND VPWR VPWR sky130_fd_sc_hd__fill_1
XFILLER_123_561 VGND VGND VPWR VPWR sky130_fd_sc_hd__decap_3
XFILLER_69_626 VGND VGND VPWR VPWR sky130_fd_sc_hd__decap_3
XFILLER_111_712 VGND VGND VPWR VPWR sky130_fd_sc_hd__decap_3
XFILLER_96_412 VGND VGND VPWR VPWR sky130_fd_sc_hd__decap_3
X_4110_ _4376_/A _4141_/A _4141_/B _4142_/C VGND VGND VPWR VPWR _4111_/B sky130_fd_sc_hd__or4_4
XFILLER_110_200 VGND VGND VPWR VPWR sky130_fd_sc_hd__decap_3
X_5090_ _5146_/B1 _5083_/X _5085_/X _5089_/Y VGND VGND VPWR VPWR _5658_/C sky130_fd_sc_hd__a31o_2
XFILLER_78_91 VGND VGND VPWR VPWR sky130_fd_sc_hd__decap_3
XFILLER_69_659 VGND VGND VPWR VPWR sky130_fd_sc_hd__decap_3
XFILLER_68_147 VGND VGND VPWR VPWR sky130_fd_sc_hd__decap_3
XFILLER_84_607 VGND VGND VPWR VPWR sky130_fd_sc_hd__decap_3
X_4041_ _7245_/Q _4430_/A2 _4428_/B1 _7149_/Q VGND VGND VPWR VPWR _4041_/X sky130_fd_sc_hd__a22o_2
XFILLER_96_489 VGND VGND VPWR VPWR sky130_fd_sc_hd__decap_3
XFILLER_83_106 VGND VGND VPWR VPWR sky130_fd_sc_hd__decap_3
XFILLER_49_350 VGND VGND VPWR VPWR sky130_fd_sc_hd__decap_3
XFILLER_110_277 VGND VGND VPWR VPWR sky130_fd_sc_hd__decap_3
XFILLER_37_534 VGND VGND VPWR VPWR sky130_fd_sc_hd__decap_3
XFILLER_92_640 VGND VGND VPWR VPWR sky130_fd_sc_hd__decap_3
XFILLER_92_651 VGND VGND VPWR VPWR sky130_fd_sc_hd__decap_3
XFILLER_64_342 VGND VGND VPWR VPWR sky130_fd_sc_hd__decap_3
XTAP_TAPCELL_ROW_69_1165 VGND VPWR sky130_fd_sc_hd__tapvpwrvgnd_1
XFILLER_52_504 VGND VGND VPWR VPWR sky130_fd_sc_hd__fill_1
XFILLER_25_718 VGND VGND VPWR VPWR sky130_fd_sc_hd__decap_3
XFILLER_25_729 VGND VGND VPWR VPWR sky130_fd_sc_hd__decap_3
XFILLER_92_684 VGND VGND VPWR VPWR sky130_fd_sc_hd__decap_3
XFILLER_64_375 VGND VGND VPWR VPWR sky130_fd_sc_hd__decap_3
XFILLER_91_172 VGND VGND VPWR VPWR sky130_fd_sc_hd__decap_3
XTAP_TAPCELL_ROW_35_724 VGND VPWR sky130_fd_sc_hd__tapvpwrvgnd_1
XFILLER_52_548 VGND VGND VPWR VPWR sky130_fd_sc_hd__decap_3
XFILLER_24_239 VGND VGND VPWR VPWR sky130_fd_sc_hd__decap_3
X_4943_ _4943_/A _4943_/B VGND VGND VPWR VPWR _4944_/C sky130_fd_sc_hd__nor2_2
XTAP_TAPCELL_ROW_82_1332 VGND VPWR sky130_fd_sc_hd__tapvpwrvgnd_1
X_4874_ _4814_/A _4849_/Y _4872_/X _4873_/X VGND VGND VPWR VPWR _4874_/X sky130_fd_sc_hd__o31a_2
X_6613_ _6613_/A VGND VGND VPWR VPWR _6613_/Y sky130_fd_sc_hd__inv_2
X_3825_ _6749_/Q _3906_/A2 _3898_/B1 _6737_/Q VGND VGND VPWR VPWR _3825_/X sky130_fd_sc_hd__a22o_2
XFILLER_32_294 VGND VGND VPWR VPWR sky130_fd_sc_hd__decap_3
X_6544_ _6544_/A VGND VGND VPWR VPWR _6544_/Y sky130_fd_sc_hd__inv_2
XPHY_EDGE_ROW_104_Left_228 VGND VGND VPWR VPWR sky130_fd_sc_hd__decap_3
X_3756_ _6798_/Q _3759_/A2 _3767_/A2 _6708_/Q _3755_/X VGND VGND VPWR VPWR _3756_/X
+ sky130_fd_sc_hd__a221o_2
XFILLER_118_344 VGND VGND VPWR VPWR sky130_fd_sc_hd__decap_3
XFILLER_118_355 VGND VGND VPWR VPWR sky130_fd_sc_hd__decap_3
X_6475_ _6640_/A VGND VGND VPWR VPWR _6475_/Y sky130_fd_sc_hd__inv_2
XFILLER_106_517 VGND VGND VPWR VPWR sky130_fd_sc_hd__decap_3
XFILLER_106_539 VGND VGND VPWR VPWR sky130_fd_sc_hd__decap_3
XTAP_TAPCELL_ROW_93_1472 VGND VPWR sky130_fd_sc_hd__tapvpwrvgnd_1
XFILLER_99_250 VGND VGND VPWR VPWR sky130_fd_sc_hd__decap_3
XFILLER_102_701 VGND VGND VPWR VPWR sky130_fd_sc_hd__decap_3
XFILLER_114_572 VGND VGND VPWR VPWR sky130_fd_sc_hd__decap_3
X_4308_ _7192_/Q _3996_/S _3380_/Y _7384_/Q VGND VGND VPWR VPWR _4308_/X sky130_fd_sc_hd__a22o_2
XFILLER_102_734 VGND VGND VPWR VPWR sky130_fd_sc_hd__fill_1
XFILLER_101_211 VGND VGND VPWR VPWR sky130_fd_sc_hd__fill_1
X_5288_ _5288_/A0 _3993_/X _5292_/S VGND VGND VPWR VPWR _7185_/D sky130_fd_sc_hd__mux2_2
XFILLER_87_456 VGND VGND VPWR VPWR sky130_fd_sc_hd__decap_3
XFILLER_114_12 VGND VGND VPWR VPWR sky130_fd_sc_hd__decap_3
X_7027_ _7406_/CLK _7027_/D _6307_/Y VGND VGND VPWR VPWR _7027_/Q sky130_fd_sc_hd__dfrtp_2
XFILLER_59_169 VGND VGND VPWR VPWR sky130_fd_sc_hd__decap_3
XPHY_EDGE_ROW_113_Left_237 VGND VGND VPWR VPWR sky130_fd_sc_hd__decap_3
X_4239_ _4628_/A _4629_/B VGND VGND VPWR VPWR _5018_/B sky130_fd_sc_hd__nor2_2
XFILLER_75_629 VGND VGND VPWR VPWR sky130_fd_sc_hd__decap_3
XFILLER_28_501 VGND VGND VPWR VPWR sky130_fd_sc_hd__decap_3
XFILLER_68_681 VGND VGND VPWR VPWR sky130_fd_sc_hd__decap_3
XFILLER_114_56 VGND VGND VPWR VPWR sky130_fd_sc_hd__decap_3
XFILLER_74_139 VGND VGND VPWR VPWR sky130_fd_sc_hd__fill_1
XFILLER_74_27 VGND VGND VPWR VPWR sky130_fd_sc_hd__fill_1
XFILLER_28_556 VGND VGND VPWR VPWR sky130_fd_sc_hd__decap_3
XFILLER_16_707 VGND VGND VPWR VPWR sky130_fd_sc_hd__decap_3
XFILLER_83_662 VGND VGND VPWR VPWR sky130_fd_sc_hd__decap_3
XFILLER_83_673 VGND VGND VPWR VPWR sky130_fd_sc_hd__decap_3
XFILLER_82_150 VGND VGND VPWR VPWR sky130_fd_sc_hd__fill_2
XFILLER_28_589 VGND VGND VPWR VPWR sky130_fd_sc_hd__decap_3
XFILLER_70_312 VGND VGND VPWR VPWR sky130_fd_sc_hd__decap_3
XFILLER_43_526 VGND VGND VPWR VPWR sky130_fd_sc_hd__decap_3
XFILLER_15_228 VGND VGND VPWR VPWR sky130_fd_sc_hd__decap_3
XFILLER_70_345 VGND VGND VPWR VPWR sky130_fd_sc_hd__decap_3
XFILLER_90_26 VGND VGND VPWR VPWR sky130_fd_sc_hd__fill_2
XFILLER_11_423 VGND VGND VPWR VPWR sky130_fd_sc_hd__decap_3
XPHY_EDGE_ROW_122_Left_246 VGND VGND VPWR VPWR sky130_fd_sc_hd__decap_3
XTAP_TAPCELL_ROW_102_1590 VGND VPWR sky130_fd_sc_hd__tapvpwrvgnd_1
XFILLER_23_53 VGND VGND VPWR VPWR sky130_fd_sc_hd__decap_3
XFILLER_7_405 VGND VGND VPWR VPWR sky130_fd_sc_hd__decap_3
XFILLER_7_427 VGND VGND VPWR VPWR sky130_fd_sc_hd__decap_3
XFILLER_7_449 VGND VGND VPWR VPWR sky130_fd_sc_hd__decap_3
XFILLER_109_333 VGND VGND VPWR VPWR sky130_fd_sc_hd__decap_3
XFILLER_99_57 VGND VGND VPWR VPWR sky130_fd_sc_hd__decap_3
XFILLER_109_377 VGND VGND VPWR VPWR sky130_fd_sc_hd__decap_3
XFILLER_3_600 VGND VGND VPWR VPWR sky130_fd_sc_hd__decap_3
XFILLER_109_399 VGND VGND VPWR VPWR sky130_fd_sc_hd__decap_3
XFILLER_3_644 VGND VGND VPWR VPWR sky130_fd_sc_hd__decap_3
XFILLER_105_561 VGND VGND VPWR VPWR sky130_fd_sc_hd__decap_3
XFILLER_3_688 VGND VGND VPWR VPWR sky130_fd_sc_hd__decap_3
XFILLER_105_594 VGND VGND VPWR VPWR sky130_fd_sc_hd__decap_3
XFILLER_120_531 VGND VGND VPWR VPWR sky130_fd_sc_hd__fill_1
XFILLER_78_456 VGND VGND VPWR VPWR sky130_fd_sc_hd__decap_3
XFILLER_120_542 VGND VGND VPWR VPWR sky130_fd_sc_hd__decap_3
XFILLER_66_618 VGND VGND VPWR VPWR sky130_fd_sc_hd__decap_3
XFILLER_38_309 VGND VGND VPWR VPWR sky130_fd_sc_hd__decap_3
XFILLER_93_404 VGND VGND VPWR VPWR sky130_fd_sc_hd__fill_2
XFILLER_78_489 VGND VGND VPWR VPWR sky130_fd_sc_hd__decap_3
XFILLER_65_106 VGND VGND VPWR VPWR sky130_fd_sc_hd__decap_3
XFILLER_120_575 VGND VGND VPWR VPWR sky130_fd_sc_hd__decap_3
XFILLER_93_426 VGND VGND VPWR VPWR sky130_fd_sc_hd__fill_2
Xsingle_cycle_cpu_579 VGND VGND VPWR VPWR instruction_out[0] single_cycle_cpu_579/LO
+ sky130_fd_sc_hd__conb_1
XFILLER_93_437 VGND VGND VPWR VPWR sky130_fd_sc_hd__fill_2
XFILLER_48_83 VGND VGND VPWR VPWR sky130_fd_sc_hd__fill_1
XFILLER_74_640 VGND VGND VPWR VPWR sky130_fd_sc_hd__decap_3
XFILLER_58_191 VGND VGND VPWR VPWR sky130_fd_sc_hd__decap_3
XFILLER_74_651 VGND VGND VPWR VPWR sky130_fd_sc_hd__decap_3
XFILLER_19_567 VGND VGND VPWR VPWR sky130_fd_sc_hd__decap_3
XFILLER_0_57 VGND VGND VPWR VPWR sky130_fd_sc_hd__fill_2
XFILLER_80_109 VGND VGND VPWR VPWR sky130_fd_sc_hd__fill_1
XFILLER_74_684 VGND VGND VPWR VPWR sky130_fd_sc_hd__decap_3
XFILLER_34_526 VGND VGND VPWR VPWR sky130_fd_sc_hd__decap_3
XFILLER_73_172 VGND VGND VPWR VPWR sky130_fd_sc_hd__decap_3
XFILLER_46_386 VGND VGND VPWR VPWR sky130_fd_sc_hd__decap_3
XFILLER_73_194 VGND VGND VPWR VPWR sky130_fd_sc_hd__decap_3
XFILLER_64_82 VGND VGND VPWR VPWR sky130_fd_sc_hd__fill_2
XFILLER_30_710 VGND VGND VPWR VPWR sky130_fd_sc_hd__decap_3
XFILLER_42_592 VGND VGND VPWR VPWR sky130_fd_sc_hd__decap_3
XTAP_TAPCELL_ROW_64_1095 VGND VPWR sky130_fd_sc_hd__tapvpwrvgnd_1
XFILLER_119_108 VGND VGND VPWR VPWR sky130_fd_sc_hd__decap_3
XFILLER_80_70 VGND VGND VPWR VPWR sky130_fd_sc_hd__decap_3
XFILLER_119_119 VGND VGND VPWR VPWR sky130_fd_sc_hd__fill_1
XPHY_EDGE_ROW_104_Right_104 VGND VGND VPWR VPWR sky130_fd_sc_hd__decap_3
X_3610_ _3610_/A _3610_/B VGND VGND VPWR VPWR _3610_/Y sky130_fd_sc_hd__nor2_2
XTAP_TAPCELL_ROW_40_782 VGND VPWR sky130_fd_sc_hd__tapvpwrvgnd_1
XTAP_TAPCELL_ROW_40_793 VGND VPWR sky130_fd_sc_hd__tapvpwrvgnd_1
X_3541_ _4376_/A _3541_/B _4460_/B VGND VGND VPWR VPWR _3541_/X sky130_fd_sc_hd__or3b_4
Xhold906 _6706_/Q VGND VGND VPWR VPWR hold906/X sky130_fd_sc_hd__dlygate4sd3_1
Xhold917 _6712_/Q VGND VGND VPWR VPWR hold917/X sky130_fd_sc_hd__dlygate4sd3_1
XFILLER_115_314 VGND VGND VPWR VPWR sky130_fd_sc_hd__decap_3
Xhold928 _6714_/Q VGND VGND VPWR VPWR hold928/X sky130_fd_sc_hd__dlygate4sd3_1
X_6260_ _6662_/A VGND VGND VPWR VPWR _6260_/Y sky130_fd_sc_hd__inv_2
Xhold939 _7031_/Q VGND VGND VPWR VPWR _5593_/A sky130_fd_sc_hd__dlygate4sd3_1
X_3472_ _7216_/Q _4349_/B1 _4341_/B1 _7120_/Q VGND VGND VPWR VPWR _3472_/X sky130_fd_sc_hd__a22o_2
X_5211_ _5211_/A _5225_/B VGND VGND VPWR VPWR _7223_/D sky130_fd_sc_hd__and2_2
XFILLER_97_721 VGND VGND VPWR VPWR sky130_fd_sc_hd__decap_3
XFILLER_97_732 VGND VGND VPWR VPWR sky130_fd_sc_hd__decap_3
X_5142_ _5142_/A0 _3993_/X _5157_/S VGND VGND VPWR VPWR _7249_/D sky130_fd_sc_hd__mux2_2
XFILLER_69_445 VGND VGND VPWR VPWR sky130_fd_sc_hd__decap_3
XFILLER_111_531 VGND VGND VPWR VPWR sky130_fd_sc_hd__decap_3
XFILLER_69_467 VGND VGND VPWR VPWR sky130_fd_sc_hd__decap_3
XFILLER_111_564 VGND VGND VPWR VPWR sky130_fd_sc_hd__decap_3
X_5073_ _5073_/A _5073_/B VGND VGND VPWR VPWR _5073_/Y sky130_fd_sc_hd__xnor2_2
XFILLER_84_415 VGND VGND VPWR VPWR sky130_fd_sc_hd__decap_3
XFILLER_57_629 VGND VGND VPWR VPWR sky130_fd_sc_hd__decap_3
XFILLER_111_597 VGND VGND VPWR VPWR sky130_fd_sc_hd__decap_3
XFILLER_56_139 VGND VGND VPWR VPWR sky130_fd_sc_hd__fill_1
XFILLER_37_331 VGND VGND VPWR VPWR sky130_fd_sc_hd__decap_3
XFILLER_65_662 VGND VGND VPWR VPWR sky130_fd_sc_hd__decap_3
XFILLER_65_673 VGND VGND VPWR VPWR sky130_fd_sc_hd__decap_3
XFILLER_37_364 VGND VGND VPWR VPWR sky130_fd_sc_hd__decap_3
XFILLER_80_610 VGND VGND VPWR VPWR sky130_fd_sc_hd__decap_3
XFILLER_64_161 VGND VGND VPWR VPWR sky130_fd_sc_hd__decap_3
XFILLER_52_301 VGND VGND VPWR VPWR sky130_fd_sc_hd__decap_3
XFILLER_52_312 VGND VGND VPWR VPWR sky130_fd_sc_hd__decap_3
XTAP_TAPCELL_ROW_48_893 VGND VPWR sky130_fd_sc_hd__tapvpwrvgnd_1
XFILLER_52_323 VGND VGND VPWR VPWR sky130_fd_sc_hd__decap_3
XFILLER_37_397 VGND VGND VPWR VPWR sky130_fd_sc_hd__fill_2
XFILLER_80_643 VGND VGND VPWR VPWR sky130_fd_sc_hd__fill_1
XFILLER_64_194 VGND VGND VPWR VPWR sky130_fd_sc_hd__fill_2
XFILLER_80_654 VGND VGND VPWR VPWR sky130_fd_sc_hd__decap_3
XFILLER_40_507 VGND VGND VPWR VPWR sky130_fd_sc_hd__decap_3
XFILLER_80_687 VGND VGND VPWR VPWR sky130_fd_sc_hd__decap_3
X_4926_ _4829_/A _4920_/Y _4925_/X VGND VGND VPWR VPWR _4926_/Y sky130_fd_sc_hd__o21ai_2
XFILLER_33_581 VGND VGND VPWR VPWR sky130_fd_sc_hd__decap_3
XFILLER_21_721 VGND VGND VPWR VPWR sky130_fd_sc_hd__decap_3
XFILLER_21_732 VGND VGND VPWR VPWR sky130_fd_sc_hd__decap_3
X_4857_ _4983_/A _5655_/D place268/X VGND VGND VPWR VPWR _4857_/X sky130_fd_sc_hd__or3b_4
XFILLER_60_29 VGND VGND VPWR VPWR sky130_fd_sc_hd__decap_3
X_3808_ _6929_/Q _3886_/A2 _3889_/A2 _6793_/Q _3807_/X VGND VGND VPWR VPWR _3808_/X
+ sky130_fd_sc_hd__a221o_2
XFILLER_119_620 VGND VGND VPWR VPWR sky130_fd_sc_hd__decap_3
X_4788_ _4788_/A _4788_/B VGND VGND VPWR VPWR _4788_/Y sky130_fd_sc_hd__nand2_2
XFILLER_20_286 VGND VGND VPWR VPWR sky130_fd_sc_hd__decap_3
XFILLER_121_9 VGND VGND VPWR VPWR sky130_fd_sc_hd__decap_3
XFILLER_119_653 VGND VGND VPWR VPWR sky130_fd_sc_hd__decap_3
XTAP_TAPCELL_ROW_95_1501 VGND VPWR sky130_fd_sc_hd__tapvpwrvgnd_1
XFILLER_118_130 VGND VGND VPWR VPWR sky130_fd_sc_hd__decap_3
XFILLER_109_12 VGND VGND VPWR VPWR sky130_fd_sc_hd__decap_3
X_6527_ _6624_/A VGND VGND VPWR VPWR _6527_/Y sky130_fd_sc_hd__inv_2
XFILLER_118_141 VGND VGND VPWR VPWR sky130_fd_sc_hd__fill_2
X_3739_ _6936_/Q _3886_/A2 _3913_/A2 _6800_/Q VGND VGND VPWR VPWR _3739_/X sky130_fd_sc_hd__a22o_2
XFILLER_4_419 VGND VGND VPWR VPWR sky130_fd_sc_hd__fill_1
XFILLER_119_697 VGND VGND VPWR VPWR sky130_fd_sc_hd__decap_3
XFILLER_109_45 VGND VGND VPWR VPWR sky130_fd_sc_hd__decap_3
X_6458_ _6651_/A VGND VGND VPWR VPWR _6458_/Y sky130_fd_sc_hd__inv_2
XFILLER_69_27 VGND VGND VPWR VPWR sky130_fd_sc_hd__decap_3
X_5409_ _5409_/A0 _5079_/X _5427_/S VGND VGND VPWR VPWR _7129_/D sky130_fd_sc_hd__mux2_2
X_6389_ _6654_/A VGND VGND VPWR VPWR _6389_/Y sky130_fd_sc_hd__inv_2
XFILLER_88_710 VGND VGND VPWR VPWR sky130_fd_sc_hd__decap_3
XFILLER_121_317 VGND VGND VPWR VPWR sky130_fd_sc_hd__decap_3
XFILLER_0_614 VGND VGND VPWR VPWR sky130_fd_sc_hd__fill_2
XFILLER_87_220 VGND VGND VPWR VPWR sky130_fd_sc_hd__decap_3
XFILLER_87_231 VGND VGND VPWR VPWR sky130_fd_sc_hd__fill_1
XFILLER_87_242 VGND VGND VPWR VPWR sky130_fd_sc_hd__decap_3
XFILLER_102_542 VGND VGND VPWR VPWR sky130_fd_sc_hd__decap_3
XFILLER_85_15 VGND VGND VPWR VPWR sky130_fd_sc_hd__fill_2
XFILLER_48_618 VGND VGND VPWR VPWR sky130_fd_sc_hd__decap_3
XFILLER_102_575 VGND VGND VPWR VPWR sky130_fd_sc_hd__decap_3
XFILLER_87_275 VGND VGND VPWR VPWR sky130_fd_sc_hd__decap_3
XFILLER_56_640 VGND VGND VPWR VPWR sky130_fd_sc_hd__decap_3
XFILLER_56_651 VGND VGND VPWR VPWR sky130_fd_sc_hd__decap_3
XFILLER_28_342 VGND VGND VPWR VPWR sky130_fd_sc_hd__decap_3
XFILLER_18_53 VGND VGND VPWR VPWR sky130_fd_sc_hd__fill_1
XFILLER_83_470 VGND VGND VPWR VPWR sky130_fd_sc_hd__decap_3
XFILLER_71_610 VGND VGND VPWR VPWR sky130_fd_sc_hd__decap_3
XFILLER_56_684 VGND VGND VPWR VPWR sky130_fd_sc_hd__decap_3
XFILLER_71_632 VGND VGND VPWR VPWR sky130_fd_sc_hd__decap_3
XFILLER_71_665 VGND VGND VPWR VPWR sky130_fd_sc_hd__decap_3
XFILLER_71_676 VGND VGND VPWR VPWR sky130_fd_sc_hd__decap_3
XFILLER_70_153 VGND VGND VPWR VPWR sky130_fd_sc_hd__decap_3
XFILLER_12_710 VGND VGND VPWR VPWR sky130_fd_sc_hd__decap_3
XFILLER_24_581 VGND VGND VPWR VPWR sky130_fd_sc_hd__decap_3
XFILLER_70_197 VGND VGND VPWR VPWR sky130_fd_sc_hd__fill_1
XFILLER_24_592 VGND VGND VPWR VPWR sky130_fd_sc_hd__decap_3
XFILLER_34_85 VGND VGND VPWR VPWR sky130_fd_sc_hd__fill_1
XFILLER_8_725 VGND VGND VPWR VPWR sky130_fd_sc_hd__decap_3
XFILLER_7_235 VGND VGND VPWR VPWR sky130_fd_sc_hd__decap_3
XFILLER_109_141 VGND VGND VPWR VPWR sky130_fd_sc_hd__decap_3
XFILLER_79_721 VGND VGND VPWR VPWR sky130_fd_sc_hd__decap_3
XFILLER_112_328 VGND VGND VPWR VPWR sky130_fd_sc_hd__decap_3
XFILLER_79_732 VGND VGND VPWR VPWR sky130_fd_sc_hd__decap_3
XFILLER_59_82 VGND VGND VPWR VPWR sky130_fd_sc_hd__decap_3
XFILLER_78_242 VGND VGND VPWR VPWR sky130_fd_sc_hd__decap_3
XFILLER_94_713 VGND VGND VPWR VPWR sky130_fd_sc_hd__decap_3
XFILLER_78_264 VGND VGND VPWR VPWR sky130_fd_sc_hd__decap_3
XFILLER_120_350 VGND VGND VPWR VPWR sky130_fd_sc_hd__decap_3
XFILLER_78_275 VGND VGND VPWR VPWR sky130_fd_sc_hd__decap_3
XFILLER_39_629 VGND VGND VPWR VPWR sky130_fd_sc_hd__decap_3
XFILLER_38_117 VGND VGND VPWR VPWR sky130_fd_sc_hd__fill_2
XFILLER_93_212 VGND VGND VPWR VPWR sky130_fd_sc_hd__decap_3
XFILLER_120_383 VGND VGND VPWR VPWR sky130_fd_sc_hd__decap_3
XFILLER_93_234 VGND VGND VPWR VPWR sky130_fd_sc_hd__decap_3
XFILLER_47_662 VGND VGND VPWR VPWR sky130_fd_sc_hd__decap_3
XFILLER_47_673 VGND VGND VPWR VPWR sky130_fd_sc_hd__decap_3
XTAP_TAPCELL_ROW_66_1124 VGND VPWR sky130_fd_sc_hd__tapvpwrvgnd_1
XFILLER_34_312 VGND VGND VPWR VPWR sky130_fd_sc_hd__decap_3
XFILLER_62_632 VGND VGND VPWR VPWR sky130_fd_sc_hd__decap_3
XFILLER_46_194 VGND VGND VPWR VPWR sky130_fd_sc_hd__fill_2
XFILLER_34_334 VGND VGND VPWR VPWR sky130_fd_sc_hd__decap_3
XFILLER_62_654 VGND VGND VPWR VPWR sky130_fd_sc_hd__decap_3
XTAP_TAPCELL_ROW_45_852 VGND VPWR sky130_fd_sc_hd__tapvpwrvgnd_1
XFILLER_62_687 VGND VGND VPWR VPWR sky130_fd_sc_hd__decap_3
XFILLER_15_570 VGND VGND VPWR VPWR sky130_fd_sc_hd__decap_3
XFILLER_98_3 VGND VGND VPWR VPWR sky130_fd_sc_hd__decap_3
XFILLER_61_197 VGND VGND VPWR VPWR sky130_fd_sc_hd__decap_3
X_4711_ _7005_/Q _7006_/Q _4775_/A VGND VGND VPWR VPWR _4738_/A sky130_fd_sc_hd__and3_2
XFILLER_30_562 VGND VGND VPWR VPWR sky130_fd_sc_hd__decap_3
X_4642_ _4207_/A _4642_/B VGND VGND VPWR VPWR _4888_/A sky130_fd_sc_hd__and2b_2
XFILLER_30_584 VGND VGND VPWR VPWR sky130_fd_sc_hd__decap_3
XFILLER_30_595 VGND VGND VPWR VPWR sky130_fd_sc_hd__decap_3
X_7361_ _7362_/CLK _7361_/D _6641_/Y VGND VGND VPWR VPWR _7361_/Q sky130_fd_sc_hd__dfrtp_2
X_4573_ _7294_/Q _4577_/B VGND VGND VPWR VPWR _7294_/D sky130_fd_sc_hd__and2_2
XFILLER_116_601 VGND VGND VPWR VPWR sky130_fd_sc_hd__decap_3
Xhold703 _6814_/Q VGND VGND VPWR VPWR _6814_/D sky130_fd_sc_hd__dlygate4sd3_1
X_6312_ _6635_/A VGND VGND VPWR VPWR _6312_/Y sky130_fd_sc_hd__inv_2
Xhold714 _6977_/Q VGND VGND VPWR VPWR _6977_/D sky130_fd_sc_hd__dlygate4sd3_1
XFILLER_116_634 VGND VGND VPWR VPWR sky130_fd_sc_hd__decap_3
XFILLER_115_111 VGND VGND VPWR VPWR sky130_fd_sc_hd__fill_1
Xhold725 _6863_/Q VGND VGND VPWR VPWR _6863_/D sky130_fd_sc_hd__dlygate4sd3_1
X_7292_ _7356_/CLK _7292_/D _6572_/Y VGND VGND VPWR VPWR _7292_/Q sky130_fd_sc_hd__dfrtp_2
XFILLER_116_645 VGND VGND VPWR VPWR sky130_fd_sc_hd__decap_3
XTAP_TAPCELL_ROW_77_1264 VGND VPWR sky130_fd_sc_hd__tapvpwrvgnd_1
Xhold736 _6778_/Q VGND VGND VPWR VPWR _6778_/D sky130_fd_sc_hd__dlygate4sd3_1
Xhold747 _6865_/Q VGND VGND VPWR VPWR _6865_/D sky130_fd_sc_hd__dlygate4sd3_1
Xhold758 _6937_/Q VGND VGND VPWR VPWR _6937_/D sky130_fd_sc_hd__dlygate4sd3_1
XFILLER_116_678 VGND VGND VPWR VPWR sky130_fd_sc_hd__decap_3
Xhold769 _6733_/Q VGND VGND VPWR VPWR _6733_/D sky130_fd_sc_hd__dlygate4sd3_1
X_3455_ _7346_/Q _4270_/B _3454_/X VGND VGND VPWR VPWR _3455_/X sky130_fd_sc_hd__a21o_2
XTAP_TAPCELL_ROW_90_1431 VGND VPWR sky130_fd_sc_hd__tapvpwrvgnd_1
XTAP_TAPCELL_ROW_90_1442 VGND VPWR sky130_fd_sc_hd__tapvpwrvgnd_1
X_3386_ _3386_/A _3386_/B VGND VGND VPWR VPWR _3386_/Y sky130_fd_sc_hd__nand2_2
X_5125_ _5156_/S _5125_/B VGND VGND VPWR VPWR _5125_/Y sky130_fd_sc_hd__nand2_2
XFILLER_97_573 VGND VGND VPWR VPWR sky130_fd_sc_hd__decap_3
XFILLER_69_264 VGND VGND VPWR VPWR sky130_fd_sc_hd__decap_3
XFILLER_85_724 VGND VGND VPWR VPWR sky130_fd_sc_hd__decap_3
XFILLER_69_275 VGND VGND VPWR VPWR sky130_fd_sc_hd__decap_3
XFILLER_57_426 VGND VGND VPWR VPWR sky130_fd_sc_hd__decap_3
XFILLER_84_223 VGND VGND VPWR VPWR sky130_fd_sc_hd__decap_3
X_5056_ _3536_/B _4619_/B _5052_/X _5055_/X VGND VGND VPWR VPWR _5056_/X sky130_fd_sc_hd__o31a_2
XFILLER_38_640 VGND VGND VPWR VPWR sky130_fd_sc_hd__decap_3
XFILLER_38_651 VGND VGND VPWR VPWR sky130_fd_sc_hd__decap_3
XFILLER_65_470 VGND VGND VPWR VPWR sky130_fd_sc_hd__decap_3
XFILLER_38_684 VGND VGND VPWR VPWR sky130_fd_sc_hd__decap_3
XFILLER_25_301 VGND VGND VPWR VPWR sky130_fd_sc_hd__fill_1
XFILLER_37_172 VGND VGND VPWR VPWR sky130_fd_sc_hd__fill_1
XFILLER_53_632 VGND VGND VPWR VPWR sky130_fd_sc_hd__decap_3
XFILLER_25_323 VGND VGND VPWR VPWR sky130_fd_sc_hd__decap_3
XFILLER_25_334 VGND VGND VPWR VPWR sky130_fd_sc_hd__fill_2
XFILLER_37_194 VGND VGND VPWR VPWR sky130_fd_sc_hd__decap_3
XFILLER_111_24 VGND VGND VPWR VPWR sky130_fd_sc_hd__decap_3
XFILLER_53_665 VGND VGND VPWR VPWR sky130_fd_sc_hd__decap_3
XFILLER_25_356 VGND VGND VPWR VPWR sky130_fd_sc_hd__decap_3
XFILLER_53_676 VGND VGND VPWR VPWR sky130_fd_sc_hd__decap_3
XFILLER_111_57 VGND VGND VPWR VPWR sky130_fd_sc_hd__decap_3
XFILLER_40_315 VGND VGND VPWR VPWR sky130_fd_sc_hd__decap_3
XFILLER_52_197 VGND VGND VPWR VPWR sky130_fd_sc_hd__fill_2
XFILLER_40_348 VGND VGND VPWR VPWR sky130_fd_sc_hd__decap_3
X_4909_ _4909_/A _4909_/B _4909_/C VGND VGND VPWR VPWR _4910_/B sky130_fd_sc_hd__or3_2
XTAP_TAPCELL_ROW_23_568 VGND VPWR sky130_fd_sc_hd__tapvpwrvgnd_1
XFILLER_21_595 VGND VGND VPWR VPWR sky130_fd_sc_hd__decap_3
XFILLER_5_706 VGND VGND VPWR VPWR sky130_fd_sc_hd__decap_3
XFILLER_119_472 VGND VGND VPWR VPWR sky130_fd_sc_hd__decap_3
XFILLER_107_612 VGND VGND VPWR VPWR sky130_fd_sc_hd__decap_3
XFILLER_107_623 VGND VGND VPWR VPWR sky130_fd_sc_hd__decap_3
XFILLER_20_32 VGND VGND VPWR VPWR sky130_fd_sc_hd__fill_2
XFILLER_106_122 VGND VGND VPWR VPWR sky130_fd_sc_hd__decap_3
XFILLER_107_656 VGND VGND VPWR VPWR sky130_fd_sc_hd__decap_3
XFILLER_122_604 VGND VGND VPWR VPWR sky130_fd_sc_hd__decap_3
XFILLER_122_637 VGND VGND VPWR VPWR sky130_fd_sc_hd__decap_3
XFILLER_122_648 VGND VGND VPWR VPWR sky130_fd_sc_hd__decap_3
XFILLER_121_125 VGND VGND VPWR VPWR sky130_fd_sc_hd__decap_3
XFILLER_88_562 VGND VGND VPWR VPWR sky130_fd_sc_hd__decap_3
XFILLER_76_713 VGND VGND VPWR VPWR sky130_fd_sc_hd__decap_3
XFILLER_102_361 VGND VGND VPWR VPWR sky130_fd_sc_hd__decap_3
XFILLER_0_488 VGND VGND VPWR VPWR sky130_fd_sc_hd__decap_3
XFILLER_88_595 VGND VGND VPWR VPWR sky130_fd_sc_hd__decap_3
XFILLER_75_223 VGND VGND VPWR VPWR sky130_fd_sc_hd__fill_1
XFILLER_48_437 VGND VGND VPWR VPWR sky130_fd_sc_hd__decap_3
XFILLER_102_383 VGND VGND VPWR VPWR sky130_fd_sc_hd__decap_3
XFILLER_29_85 VGND VGND VPWR VPWR sky130_fd_sc_hd__decap_3
XFILLER_75_245 VGND VGND VPWR VPWR sky130_fd_sc_hd__decap_3
XFILLER_75_267 VGND VGND VPWR VPWR sky130_fd_sc_hd__fill_2
XFILLER_91_727 VGND VGND VPWR VPWR sky130_fd_sc_hd__fill_1
XFILLER_29_662 VGND VGND VPWR VPWR sky130_fd_sc_hd__decap_3
XFILLER_29_673 VGND VGND VPWR VPWR sky130_fd_sc_hd__decap_3
Xplace407 _4532_/S VGND VGND VPWR VPWR _4528_/B sky130_fd_sc_hd__buf_2
XFILLER_90_226 VGND VGND VPWR VPWR sky130_fd_sc_hd__decap_3
XFILLER_44_621 VGND VGND VPWR VPWR sky130_fd_sc_hd__decap_3
XFILLER_16_312 VGND VGND VPWR VPWR sky130_fd_sc_hd__decap_3
Xplace418 _3376_/Y VGND VGND VPWR VPWR _5161_/A sky130_fd_sc_hd__buf_2
Xplace429 _3996_/S VGND VGND VPWR VPWR _3966_/S sky130_fd_sc_hd__buf_2
XFILLER_56_492 VGND VGND VPWR VPWR sky130_fd_sc_hd__decap_3
XFILLER_90_248 VGND VGND VPWR VPWR sky130_fd_sc_hd__decap_3
XFILLER_28_194 VGND VGND VPWR VPWR sky130_fd_sc_hd__fill_2
XFILLER_90_259 VGND VGND VPWR VPWR sky130_fd_sc_hd__decap_3
XFILLER_71_440 VGND VGND VPWR VPWR sky130_fd_sc_hd__decap_3
XFILLER_44_654 VGND VGND VPWR VPWR sky130_fd_sc_hd__decap_3
XFILLER_45_73 VGND VGND VPWR VPWR sky130_fd_sc_hd__decap_3
XFILLER_71_462 VGND VGND VPWR VPWR sky130_fd_sc_hd__decap_3
XFILLER_45_84 VGND VGND VPWR VPWR sky130_fd_sc_hd__decap_3
XFILLER_44_687 VGND VGND VPWR VPWR sky130_fd_sc_hd__decap_3
XTAP_TAPCELL_ROW_42_811 VGND VPWR sky130_fd_sc_hd__tapvpwrvgnd_1
XFILLER_31_326 VGND VGND VPWR VPWR sky130_fd_sc_hd__decap_3
XFILLER_31_337 VGND VGND VPWR VPWR sky130_fd_sc_hd__decap_3
XTAP_TAPCELL_ROW_61_1054 VGND VPWR sky130_fd_sc_hd__tapvpwrvgnd_1
XFILLER_12_562 VGND VGND VPWR VPWR sky130_fd_sc_hd__decap_3
XTAP_TAPCELL_ROW_61_1065 VGND VPWR sky130_fd_sc_hd__tapvpwrvgnd_1
XFILLER_8_522 VGND VGND VPWR VPWR sky130_fd_sc_hd__decap_3
XFILLER_8_533 VGND VGND VPWR VPWR sky130_fd_sc_hd__decap_3
XFILLER_12_595 VGND VGND VPWR VPWR sky130_fd_sc_hd__decap_3
XFILLER_8_566 VGND VGND VPWR VPWR sky130_fd_sc_hd__decap_3
XANTENNA_5 _3331_/A VGND VGND VPWR VPWR sky130_fd_sc_hd__diode_2
XFILLER_113_615 VGND VGND VPWR VPWR sky130_fd_sc_hd__fill_1
XFILLER_98_315 VGND VGND VPWR VPWR sky130_fd_sc_hd__fill_2
XFILLER_113_626 VGND VGND VPWR VPWR sky130_fd_sc_hd__decap_3
XFILLER_113_659 VGND VGND VPWR VPWR sky130_fd_sc_hd__decap_3
XFILLER_79_540 VGND VGND VPWR VPWR sky130_fd_sc_hd__decap_3
XFILLER_3_293 VGND VGND VPWR VPWR sky130_fd_sc_hd__decap_3
XFILLER_67_724 VGND VGND VPWR VPWR sky130_fd_sc_hd__decap_3
XFILLER_86_80 VGND VGND VPWR VPWR sky130_fd_sc_hd__decap_3
XFILLER_66_234 VGND VGND VPWR VPWR sky130_fd_sc_hd__decap_3
XFILLER_94_565 VGND VGND VPWR VPWR sky130_fd_sc_hd__decap_3
XFILLER_66_256 VGND VGND VPWR VPWR sky130_fd_sc_hd__decap_3
XFILLER_82_716 VGND VGND VPWR VPWR sky130_fd_sc_hd__decap_3
X_6930_ _7215_/CLK _6930_/D VGND VGND VPWR VPWR _6930_/Q sky130_fd_sc_hd__dfxtp_2
XFILLER_94_598 VGND VGND VPWR VPWR sky130_fd_sc_hd__decap_3
XFILLER_66_289 VGND VGND VPWR VPWR sky130_fd_sc_hd__decap_3
XFILLER_19_172 VGND VGND VPWR VPWR sky130_fd_sc_hd__decap_3
XFILLER_81_237 VGND VGND VPWR VPWR sky130_fd_sc_hd__decap_3
XFILLER_35_632 VGND VGND VPWR VPWR sky130_fd_sc_hd__decap_3
X_6861_ clkload4/A _6861_/D VGND VGND VPWR VPWR _6861_/Q sky130_fd_sc_hd__dfxtp_2
XFILLER_62_451 VGND VGND VPWR VPWR sky130_fd_sc_hd__decap_3
XFILLER_35_665 VGND VGND VPWR VPWR sky130_fd_sc_hd__decap_3
XFILLER_35_676 VGND VGND VPWR VPWR sky130_fd_sc_hd__decap_3
XFILLER_50_613 VGND VGND VPWR VPWR sky130_fd_sc_hd__decap_3
X_6792_ _6926_/CLK _6792_/D VGND VGND VPWR VPWR _6792_/Q sky130_fd_sc_hd__dfxtp_2
XFILLER_34_186 VGND VGND VPWR VPWR sky130_fd_sc_hd__decap_3
XFILLER_22_337 VGND VGND VPWR VPWR sky130_fd_sc_hd__decap_3
XFILLER_50_657 VGND VGND VPWR VPWR sky130_fd_sc_hd__decap_3
XTAP_TAPCELL_ROW_20_527 VGND VPWR sky130_fd_sc_hd__tapvpwrvgnd_1
X_5674_ _7343_/Q hold910/X _5712_/S VGND VGND VPWR VPWR _6687_/D sky130_fd_sc_hd__mux2_2
X_4625_ _5099_/A _4625_/A2 _4624_/B _4624_/X VGND VGND VPWR VPWR _4916_/A sky130_fd_sc_hd__a31oi_4
X_7344_ _7345_/CLK _7344_/D _6624_/Y VGND VGND VPWR VPWR _7344_/Q sky130_fd_sc_hd__dfrtp_2
X_4556_ _4556_/A _4559_/B VGND VGND VPWR VPWR _7302_/D sky130_fd_sc_hd__and2_2
XFILLER_104_604 VGND VGND VPWR VPWR sky130_fd_sc_hd__decap_3
X_3507_ _3458_/Y _3505_/X _3506_/Y VGND VGND VPWR VPWR _3508_/B sky130_fd_sc_hd__o21a_2
X_7275_ _7399_/CLK _7275_/D _6555_/Y VGND VGND VPWR VPWR _7275_/Q sky130_fd_sc_hd__dfrtp_2
XFILLER_116_475 VGND VGND VPWR VPWR sky130_fd_sc_hd__fill_1
XFILLER_103_103 VGND VGND VPWR VPWR sky130_fd_sc_hd__decap_3
XFILLER_116_497 VGND VGND VPWR VPWR sky130_fd_sc_hd__decap_3
XFILLER_104_637 VGND VGND VPWR VPWR sky130_fd_sc_hd__decap_3
Xhold588 _6922_/Q VGND VGND VPWR VPWR _6922_/D sky130_fd_sc_hd__dlygate4sd3_1
XFILLER_89_337 VGND VGND VPWR VPWR sky130_fd_sc_hd__decap_3
XFILLER_104_648 VGND VGND VPWR VPWR sky130_fd_sc_hd__decap_3
XFILLER_89_348 VGND VGND VPWR VPWR sky130_fd_sc_hd__decap_3
X_3438_ _7314_/Q _3989_/S _4346_/B1 _7346_/Q _4248_/A VGND VGND VPWR VPWR _3438_/X
+ sky130_fd_sc_hd__a221o_2
Xhold599 _6846_/Q VGND VGND VPWR VPWR _6846_/D sky130_fd_sc_hd__dlygate4sd3_1
XFILLER_103_136 VGND VGND VPWR VPWR sky130_fd_sc_hd__decap_3
XFILLER_106_24 VGND VGND VPWR VPWR sky130_fd_sc_hd__decap_3
XFILLER_103_147 VGND VGND VPWR VPWR sky130_fd_sc_hd__decap_3
XFILLER_106_35 VGND VGND VPWR VPWR sky130_fd_sc_hd__fill_1
XFILLER_103_169 VGND VGND VPWR VPWR sky130_fd_sc_hd__decap_3
XFILLER_58_713 VGND VGND VPWR VPWR sky130_fd_sc_hd__decap_3
X_3369_ _3371_/A _5668_/A VGND VGND VPWR VPWR _3560_/B sky130_fd_sc_hd__nand2_2
Xhold1200 _7329_/Q VGND VGND VPWR VPWR _4501_/A0 sky130_fd_sc_hd__dlygate4sd3_1
XFILLER_97_370 VGND VGND VPWR VPWR sky130_fd_sc_hd__decap_3
XFILLER_112_681 VGND VGND VPWR VPWR sky130_fd_sc_hd__decap_3
Xhold1211 _7143_/Q VGND VGND VPWR VPWR _5379_/A0 sky130_fd_sc_hd__dlygate4sd3_1
XFILLER_57_212 VGND VGND VPWR VPWR sky130_fd_sc_hd__decap_3
XFILLER_106_79 VGND VGND VPWR VPWR sky130_fd_sc_hd__decap_3
XFILLER_85_532 VGND VGND VPWR VPWR sky130_fd_sc_hd__decap_3
X_5108_ _5108_/A0 _5107_/X _5157_/S VGND VGND VPWR VPWR _7255_/D sky130_fd_sc_hd__mux2_2
XFILLER_57_234 VGND VGND VPWR VPWR sky130_fd_sc_hd__decap_3
XFILLER_85_576 VGND VGND VPWR VPWR sky130_fd_sc_hd__decap_3
XFILLER_73_727 VGND VGND VPWR VPWR sky130_fd_sc_hd__fill_1
XFILLER_57_278 VGND VGND VPWR VPWR sky130_fd_sc_hd__fill_2
XFILLER_122_23 VGND VGND VPWR VPWR sky130_fd_sc_hd__decap_3
X_5039_ _4677_/B _3856_/X _5658_/B _5038_/X _5647_/A VGND VGND VPWR VPWR _5039_/X
+ sky130_fd_sc_hd__o32a_2
XTAP_TAPCELL_ROW_28_627 VGND VPWR sky130_fd_sc_hd__tapvpwrvgnd_1
XFILLER_26_610 VGND VGND VPWR VPWR sky130_fd_sc_hd__decap_3
XFILLER_122_56 VGND VGND VPWR VPWR sky130_fd_sc_hd__decap_3
XFILLER_26_643 VGND VGND VPWR VPWR sky130_fd_sc_hd__fill_1
XTAP_TAPCELL_ROW_0_252 VGND VPWR sky130_fd_sc_hd__tapvpwrvgnd_1
XFILLER_82_27 VGND VGND VPWR VPWR sky130_fd_sc_hd__fill_1
XFILLER_26_654 VGND VGND VPWR VPWR sky130_fd_sc_hd__decap_3
XTAP_TAPCELL_ROW_0_263 VGND VPWR sky130_fd_sc_hd__tapvpwrvgnd_1
XFILLER_82_38 VGND VGND VPWR VPWR sky130_fd_sc_hd__decap_3
XFILLER_41_613 VGND VGND VPWR VPWR sky130_fd_sc_hd__decap_3
XFILLER_26_687 VGND VGND VPWR VPWR sky130_fd_sc_hd__decap_3
XFILLER_53_473 VGND VGND VPWR VPWR sky130_fd_sc_hd__decap_3
XFILLER_41_635 VGND VGND VPWR VPWR sky130_fd_sc_hd__decap_3
XFILLER_25_197 VGND VGND VPWR VPWR sky130_fd_sc_hd__decap_3
XFILLER_15_54 VGND VGND VPWR VPWR sky130_fd_sc_hd__fill_2
XFILLER_13_337 VGND VGND VPWR VPWR sky130_fd_sc_hd__decap_3
XFILLER_80_292 VGND VGND VPWR VPWR sky130_fd_sc_hd__decap_3
XFILLER_13_359 VGND VGND VPWR VPWR sky130_fd_sc_hd__decap_3
XFILLER_41_668 VGND VGND VPWR VPWR sky130_fd_sc_hd__decap_3
XFILLER_41_679 VGND VGND VPWR VPWR sky130_fd_sc_hd__decap_3
XFILLER_31_20 VGND VGND VPWR VPWR sky130_fd_sc_hd__fill_2
XFILLER_5_525 VGND VGND VPWR VPWR sky130_fd_sc_hd__decap_3
XFILLER_107_420 VGND VGND VPWR VPWR sky130_fd_sc_hd__fill_2
XFILLER_5_558 VGND VGND VPWR VPWR sky130_fd_sc_hd__fill_2
XFILLER_107_475 VGND VGND VPWR VPWR sky130_fd_sc_hd__decap_3
XFILLER_107_497 VGND VGND VPWR VPWR sky130_fd_sc_hd__decap_3
XFILLER_1_720 VGND VGND VPWR VPWR sky130_fd_sc_hd__decap_3
XFILLER_122_456 VGND VGND VPWR VPWR sky130_fd_sc_hd__decap_3
XFILLER_110_607 VGND VGND VPWR VPWR sky130_fd_sc_hd__decap_3
XTAP_TAPCELL_ROW_8_374 VGND VPWR sky130_fd_sc_hd__tapvpwrvgnd_1
XFILLER_95_307 VGND VGND VPWR VPWR sky130_fd_sc_hd__decap_3
XFILLER_95_329 VGND VGND VPWR VPWR sky130_fd_sc_hd__decap_3
XFILLER_122_489 VGND VGND VPWR VPWR sky130_fd_sc_hd__decap_3
XFILLER_49_724 VGND VGND VPWR VPWR sky130_fd_sc_hd__decap_3
XFILLER_48_201 VGND VGND VPWR VPWR sky130_fd_sc_hd__fill_1
XFILLER_0_274 VGND VGND VPWR VPWR sky130_fd_sc_hd__decap_3
XFILLER_48_223 VGND VGND VPWR VPWR sky130_fd_sc_hd__decap_3
XFILLER_0_296 VGND VGND VPWR VPWR sky130_fd_sc_hd__decap_3
XFILLER_88_392 VGND VGND VPWR VPWR sky130_fd_sc_hd__decap_3
XFILLER_102_191 VGND VGND VPWR VPWR sky130_fd_sc_hd__decap_3
XFILLER_48_256 VGND VGND VPWR VPWR sky130_fd_sc_hd__decap_3
XFILLER_91_502 VGND VGND VPWR VPWR sky130_fd_sc_hd__fill_2
XFILLER_64_716 VGND VGND VPWR VPWR sky130_fd_sc_hd__decap_3
XFILLER_36_418 VGND VGND VPWR VPWR sky130_fd_sc_hd__fill_2
XFILLER_76_598 VGND VGND VPWR VPWR sky130_fd_sc_hd__decap_3
XFILLER_17_632 VGND VGND VPWR VPWR sky130_fd_sc_hd__decap_3
XFILLER_91_579 VGND VGND VPWR VPWR sky130_fd_sc_hd__decap_3
XFILLER_17_665 VGND VGND VPWR VPWR sky130_fd_sc_hd__decap_3
XFILLER_44_451 VGND VGND VPWR VPWR sky130_fd_sc_hd__decap_3
XFILLER_17_676 VGND VGND VPWR VPWR sky130_fd_sc_hd__decap_3
XFILLER_32_613 VGND VGND VPWR VPWR sky130_fd_sc_hd__decap_3
XFILLER_16_164 VGND VGND VPWR VPWR sky130_fd_sc_hd__decap_3
XTAP_TAPCELL_ROW_55_980 VGND VPWR sky130_fd_sc_hd__tapvpwrvgnd_1
XFILLER_71_281 VGND VGND VPWR VPWR sky130_fd_sc_hd__fill_1
XTAP_TAPCELL_ROW_123_1880 VGND VPWR sky130_fd_sc_hd__tapvpwrvgnd_1
XFILLER_16_197 VGND VGND VPWR VPWR sky130_fd_sc_hd__decap_3
XFILLER_32_657 VGND VGND VPWR VPWR sky130_fd_sc_hd__decap_3
XFILLER_72_82 VGND VGND VPWR VPWR sky130_fd_sc_hd__fill_2
XFILLER_82_6 VGND VGND VPWR VPWR sky130_fd_sc_hd__decap_3
XFILLER_31_189 VGND VGND VPWR VPWR sky130_fd_sc_hd__fill_2
XFILLER_8_330 VGND VGND VPWR VPWR sky130_fd_sc_hd__decap_3
XFILLER_40_690 VGND VGND VPWR VPWR sky130_fd_sc_hd__decap_3
XFILLER_118_707 VGND VGND VPWR VPWR sky130_fd_sc_hd__decap_3
XFILLER_12_392 VGND VGND VPWR VPWR sky130_fd_sc_hd__decap_3
XFILLER_117_217 VGND VGND VPWR VPWR sky130_fd_sc_hd__decap_3
XFILLER_117_228 VGND VGND VPWR VPWR sky130_fd_sc_hd__decap_3
XFILLER_8_385 VGND VGND VPWR VPWR sky130_fd_sc_hd__decap_3
X_4410_ _4411_/A _4411_/B VGND VGND VPWR VPWR _4788_/B sky130_fd_sc_hd__nor2_2
X_5390_ _5390_/A0 _4932_/X _5398_/S VGND VGND VPWR VPWR _7138_/D sky130_fd_sc_hd__mux2_2
XTAP_TAPCELL_ROW_74_1223 VGND VPWR sky130_fd_sc_hd__tapvpwrvgnd_1
X_4341_ _7255_/Q _4601_/S _4341_/B1 _7127_/Q _4340_/X VGND VGND VPWR VPWR _4365_/A
+ sky130_fd_sc_hd__a221o_2
XTAP_TAPCELL_ROW_74_1234 VGND VPWR sky130_fd_sc_hd__tapvpwrvgnd_1
XFILLER_99_635 VGND VGND VPWR VPWR sky130_fd_sc_hd__decap_3
XFILLER_98_112 VGND VGND VPWR VPWR sky130_fd_sc_hd__decap_3
X_7060_ clkload6/A _7060_/D _6340_/Y VGND VGND VPWR VPWR _7060_/Q sky130_fd_sc_hd__dfrtp_2
XFILLER_99_668 VGND VGND VPWR VPWR sky130_fd_sc_hd__decap_3
X_4272_ _4394_/A _4337_/B _4271_/X VGND VGND VPWR VPWR _4273_/D sky130_fd_sc_hd__or3b_2
XFILLER_99_679 VGND VGND VPWR VPWR sky130_fd_sc_hd__decap_3
XFILLER_86_318 VGND VGND VPWR VPWR sky130_fd_sc_hd__decap_3
XFILLER_101_629 VGND VGND VPWR VPWR sky130_fd_sc_hd__decap_3
XFILLER_39_212 VGND VGND VPWR VPWR sky130_fd_sc_hd__decap_3
XFILLER_79_381 VGND VGND VPWR VPWR sky130_fd_sc_hd__fill_2
XFILLER_39_234 VGND VGND VPWR VPWR sky130_fd_sc_hd__decap_3
XFILLER_55_727 VGND VGND VPWR VPWR sky130_fd_sc_hd__fill_1
XFILLER_27_418 VGND VGND VPWR VPWR sky130_fd_sc_hd__decap_3
XFILLER_39_289 VGND VGND VPWR VPWR sky130_fd_sc_hd__decap_3
XFILLER_54_226 VGND VGND VPWR VPWR sky130_fd_sc_hd__decap_3
X_6913_ _6926_/CLK _6913_/D VGND VGND VPWR VPWR _6913_/Q sky130_fd_sc_hd__dfxtp_2
XFILLER_82_568 VGND VGND VPWR VPWR sky130_fd_sc_hd__decap_3
XFILLER_54_259 VGND VGND VPWR VPWR sky130_fd_sc_hd__decap_3
XFILLER_70_719 VGND VGND VPWR VPWR sky130_fd_sc_hd__decap_3
XTAP_TAPCELL_ROW_85_1374 VGND VPWR sky130_fd_sc_hd__tapvpwrvgnd_1
XFILLER_23_613 VGND VGND VPWR VPWR sky130_fd_sc_hd__decap_3
X_6844_ clkload5/A _6844_/D VGND VGND VPWR VPWR _6844_/Q sky130_fd_sc_hd__dfxtp_2
XFILLER_23_635 VGND VGND VPWR VPWR sky130_fd_sc_hd__decap_3
XFILLER_62_281 VGND VGND VPWR VPWR sky130_fd_sc_hd__decap_3
XFILLER_50_421 VGND VGND VPWR VPWR sky130_fd_sc_hd__decap_3
XFILLER_23_668 VGND VGND VPWR VPWR sky130_fd_sc_hd__decap_3
XFILLER_23_679 VGND VGND VPWR VPWR sky130_fd_sc_hd__decap_3
X_3987_ _7347_/Q _4528_/A _3987_/S VGND VGND VPWR VPWR _7347_/D sky130_fd_sc_hd__mux2_2
X_6775_ clkload9/A _6775_/D VGND VGND VPWR VPWR _6775_/Q sky130_fd_sc_hd__dfxtp_2
XTAP_TAPCELL_ROW_33_696 VGND VPWR sky130_fd_sc_hd__tapvpwrvgnd_1
XFILLER_109_718 VGND VGND VPWR VPWR sky130_fd_sc_hd__decap_3
XFILLER_109_729 VGND VGND VPWR VPWR sky130_fd_sc_hd__decap_3
X_5657_ _5657_/A _5657_/B _5657_/C _5657_/D VGND VGND VPWR VPWR _5664_/C sky130_fd_sc_hd__nor4_2
XFILLER_108_217 VGND VGND VPWR VPWR sky130_fd_sc_hd__decap_3
X_4608_ _4938_/A _4608_/B VGND VGND VPWR VPWR _4608_/Y sky130_fd_sc_hd__nor2_2
XFILLER_117_12 VGND VGND VPWR VPWR sky130_fd_sc_hd__decap_3
X_7327_ _7359_/CLK _7327_/D _6607_/Y VGND VGND VPWR VPWR _7327_/Q sky130_fd_sc_hd__dfrtp_2
XFILLER_2_528 VGND VGND VPWR VPWR sky130_fd_sc_hd__decap_3
XFILLER_2_539 VGND VGND VPWR VPWR sky130_fd_sc_hd__decap_3
XFILLER_117_45 VGND VGND VPWR VPWR sky130_fd_sc_hd__decap_3
XFILLER_116_283 VGND VGND VPWR VPWR sky130_fd_sc_hd__decap_3
XFILLER_104_445 VGND VGND VPWR VPWR sky130_fd_sc_hd__decap_3
X_7258_ _7325_/CLK _7258_/D _6538_/Y VGND VGND VPWR VPWR _7258_/Q sky130_fd_sc_hd__dfrtp_2
XFILLER_117_78 VGND VGND VPWR VPWR sky130_fd_sc_hd__decap_3
XFILLER_89_156 VGND VGND VPWR VPWR sky130_fd_sc_hd__decap_3
XFILLER_104_489 VGND VGND VPWR VPWR sky130_fd_sc_hd__fill_2
X_7189_ _7387_/CLK _7189_/D _6469_/Y VGND VGND VPWR VPWR _7189_/Q sky130_fd_sc_hd__dfrtp_2
XTAP_TAPCELL_ROW_5_333 VGND VPWR sky130_fd_sc_hd__tapvpwrvgnd_1
XFILLER_98_690 VGND VGND VPWR VPWR sky130_fd_sc_hd__decap_3
XFILLER_100_640 VGND VGND VPWR VPWR sky130_fd_sc_hd__decap_3
Xhold1030 _7273_/Q VGND VGND VPWR VPWR _4807_/A0 sky130_fd_sc_hd__dlygate4sd3_1
XFILLER_85_340 VGND VGND VPWR VPWR sky130_fd_sc_hd__fill_2
XFILLER_100_651 VGND VGND VPWR VPWR sky130_fd_sc_hd__decap_3
Xhold1041 _7021_/Q VGND VGND VPWR VPWR _5613_/A sky130_fd_sc_hd__dlygate4sd3_1
XFILLER_85_351 VGND VGND VPWR VPWR sky130_fd_sc_hd__decap_3
XFILLER_46_716 VGND VGND VPWR VPWR sky130_fd_sc_hd__decap_3
Xhold1052 _7228_/Q VGND VGND VPWR VPWR _5200_/A sky130_fd_sc_hd__dlygate4sd3_1
XFILLER_58_587 VGND VGND VPWR VPWR sky130_fd_sc_hd__fill_1
Xhold1063 _7264_/Q VGND VGND VPWR VPWR _4965_/A0 sky130_fd_sc_hd__dlygate4sd3_1
XFILLER_73_524 VGND VGND VPWR VPWR sky130_fd_sc_hd__fill_1
XFILLER_100_684 VGND VGND VPWR VPWR sky130_fd_sc_hd__decap_3
Xhold1074 _7304_/Q VGND VGND VPWR VPWR _4552_/A sky130_fd_sc_hd__dlygate4sd3_1
Xhold1085 _7122_/Q VGND VGND VPWR VPWR _5423_/A0 sky130_fd_sc_hd__dlygate4sd3_1
XFILLER_73_546 VGND VGND VPWR VPWR sky130_fd_sc_hd__decap_3
XFILLER_45_237 VGND VGND VPWR VPWR sky130_fd_sc_hd__decap_3
Xhold1096 _7144_/Q VGND VGND VPWR VPWR _5377_/A0 sky130_fd_sc_hd__dlygate4sd3_1
XFILLER_45_259 VGND VGND VPWR VPWR sky130_fd_sc_hd__decap_3
XFILLER_26_440 VGND VGND VPWR VPWR sky130_fd_sc_hd__fill_1
Xclkbuf_3_6__f_clk clkbuf_0_clk/X VGND VGND VPWR VPWR clkbuf_3_6__f_clk/X sky130_fd_sc_hd__clkbuf_16
XFILLER_14_613 VGND VGND VPWR VPWR sky130_fd_sc_hd__decap_3
XFILLER_53_281 VGND VGND VPWR VPWR sky130_fd_sc_hd__decap_3
XFILLER_14_657 VGND VGND VPWR VPWR sky130_fd_sc_hd__decap_3
XFILLER_9_116 VGND VGND VPWR VPWR sky130_fd_sc_hd__decap_3
XFILLER_13_189 VGND VGND VPWR VPWR sky130_fd_sc_hd__decap_3
XFILLER_22_690 VGND VGND VPWR VPWR sky130_fd_sc_hd__decap_3
XFILLER_42_85 VGND VGND VPWR VPWR sky130_fd_sc_hd__decap_3
XFILLER_5_311 VGND VGND VPWR VPWR sky130_fd_sc_hd__decap_3
XFILLER_5_355 VGND VGND VPWR VPWR sky130_fd_sc_hd__fill_1
XFILLER_114_209 VGND VGND VPWR VPWR sky130_fd_sc_hd__decap_3
XFILLER_123_710 VGND VGND VPWR VPWR sky130_fd_sc_hd__decap_3
XFILLER_107_261 VGND VGND VPWR VPWR sky130_fd_sc_hd__decap_3
XFILLER_123_732 VGND VGND VPWR VPWR sky130_fd_sc_hd__decap_3
XFILLER_96_616 VGND VGND VPWR VPWR sky130_fd_sc_hd__decap_3
XFILLER_3_35 VGND VGND VPWR VPWR sky130_fd_sc_hd__decap_3
XFILLER_1_550 VGND VGND VPWR VPWR sky130_fd_sc_hd__decap_3
XFILLER_1_561 VGND VGND VPWR VPWR sky130_fd_sc_hd__decap_3
XFILLER_95_126 VGND VGND VPWR VPWR sky130_fd_sc_hd__decap_3
XFILLER_1_594 VGND VGND VPWR VPWR sky130_fd_sc_hd__decap_3
XFILLER_67_60 VGND VGND VPWR VPWR sky130_fd_sc_hd__decap_3
XFILLER_49_543 VGND VGND VPWR VPWR sky130_fd_sc_hd__decap_3
XFILLER_37_727 VGND VGND VPWR VPWR sky130_fd_sc_hd__fill_1
XFILLER_91_310 VGND VGND VPWR VPWR sky130_fd_sc_hd__decap_3
XFILLER_36_215 VGND VGND VPWR VPWR sky130_fd_sc_hd__decap_3
XFILLER_91_343 VGND VGND VPWR VPWR sky130_fd_sc_hd__decap_3
XFILLER_36_259 VGND VGND VPWR VPWR sky130_fd_sc_hd__decap_3
XFILLER_17_440 VGND VGND VPWR VPWR sky130_fd_sc_hd__decap_3
XFILLER_52_719 VGND VGND VPWR VPWR sky130_fd_sc_hd__decap_3
XFILLER_17_473 VGND VGND VPWR VPWR sky130_fd_sc_hd__fill_1
X_3910_ _6916_/Q _3926_/A2 _3913_/A2 _6780_/Q VGND VGND VPWR VPWR _3910_/X sky130_fd_sc_hd__a22o_2
X_4890_ _5101_/A _4890_/B VGND VGND VPWR VPWR _4890_/Y sky130_fd_sc_hd__nor2_2
XTAP_TAPCELL_ROW_121_1839 VGND VPWR sky130_fd_sc_hd__tapvpwrvgnd_1
X_3841_ _6845_/Q _3851_/A2 _5660_/B _6830_/Q _3840_/X VGND VGND VPWR VPWR _3841_/X
+ sky130_fd_sc_hd__a221o_2
XPHY_EDGE_ROW_17_Left_141 VGND VGND VPWR VPWR sky130_fd_sc_hd__decap_3
XFILLER_32_465 VGND VGND VPWR VPWR sky130_fd_sc_hd__decap_3
XFILLER_20_616 VGND VGND VPWR VPWR sky130_fd_sc_hd__decap_3
XFILLER_32_498 VGND VGND VPWR VPWR sky130_fd_sc_hd__decap_3
X_3772_ _6854_/Q _3884_/B1 _3883_/B1 _6902_/Q _3771_/X VGND VGND VPWR VPWR _3772_/X
+ sky130_fd_sc_hd__a221o_2
X_6560_ _6633_/A VGND VGND VPWR VPWR _6560_/Y sky130_fd_sc_hd__inv_2
XFILLER_9_650 VGND VGND VPWR VPWR sky130_fd_sc_hd__decap_3
XFILLER_118_504 VGND VGND VPWR VPWR sky130_fd_sc_hd__decap_3
XTAP_TAPCELL_ROW_30_655 VGND VPWR sky130_fd_sc_hd__tapvpwrvgnd_1
X_6491_ _6684_/A VGND VGND VPWR VPWR _6491_/Y sky130_fd_sc_hd__inv_2
XFILLER_9_694 VGND VGND VPWR VPWR sky130_fd_sc_hd__decap_3
XFILLER_118_548 VGND VGND VPWR VPWR sky130_fd_sc_hd__decap_3
XFILLER_8_182 VGND VGND VPWR VPWR sky130_fd_sc_hd__decap_3
XFILLER_114_710 VGND VGND VPWR VPWR sky130_fd_sc_hd__decap_3
X_5373_ _5373_/A0 _4792_/X _5383_/S VGND VGND VPWR VPWR _7146_/D sky130_fd_sc_hd__mux2_2
XFILLER_99_432 VGND VGND VPWR VPWR sky130_fd_sc_hd__decap_3
X_4324_ _7039_/Q _3488_/B _4354_/B1 _7386_/Q VGND VGND VPWR VPWR _4324_/X sky130_fd_sc_hd__a22o_2
X_7112_ _7374_/CLK _7112_/D _6392_/Y VGND VGND VPWR VPWR _7112_/Q sky130_fd_sc_hd__dfrtp_2
Xoutput468 _4973_/B VGND VGND VPWR VPWR alu_result_out[16] sky130_fd_sc_hd__clkdlybuf4s25_1
XFILLER_113_231 VGND VGND VPWR VPWR sky130_fd_sc_hd__decap_3
XPHY_EDGE_ROW_26_Left_150 VGND VGND VPWR VPWR sky130_fd_sc_hd__decap_3
Xoutput479 _5656_/A VGND VGND VPWR VPWR alu_result_out[26] sky130_fd_sc_hd__clkdlybuf4s25_1
XFILLER_101_404 VGND VGND VPWR VPWR sky130_fd_sc_hd__decap_3
X_7043_ _7362_/CLK _7043_/D _6323_/Y VGND VGND VPWR VPWR _7043_/Q sky130_fd_sc_hd__dfrtp_2
X_4255_ _4251_/X _4254_/X _4327_/A VGND VGND VPWR VPWR _4256_/C sky130_fd_sc_hd__o21ai_2
XFILLER_87_638 VGND VGND VPWR VPWR sky130_fd_sc_hd__decap_3
XFILLER_113_275 VGND VGND VPWR VPWR sky130_fd_sc_hd__decap_3
XFILLER_101_437 VGND VGND VPWR VPWR sky130_fd_sc_hd__decap_3
XFILLER_67_340 VGND VGND VPWR VPWR sky130_fd_sc_hd__decap_3
X_4186_ _4186_/A _4636_/B VGND VGND VPWR VPWR _4200_/A sky130_fd_sc_hd__xnor2_2
XFILLER_67_351 VGND VGND VPWR VPWR sky130_fd_sc_hd__decap_3
XFILLER_28_716 VGND VGND VPWR VPWR sky130_fd_sc_hd__decap_3
XTAP_TAPCELL_ROW_87_1403 VGND VPWR sky130_fd_sc_hd__tapvpwrvgnd_1
XFILLER_95_671 VGND VGND VPWR VPWR sky130_fd_sc_hd__fill_1
XFILLER_95_682 VGND VGND VPWR VPWR sky130_fd_sc_hd__decap_3
XFILLER_27_215 VGND VGND VPWR VPWR sky130_fd_sc_hd__decap_3
XFILLER_55_546 VGND VGND VPWR VPWR sky130_fd_sc_hd__decap_3
XFILLER_27_248 VGND VGND VPWR VPWR sky130_fd_sc_hd__decap_3
XTAP_TAPCELL_ROW_38_755 VGND VPWR sky130_fd_sc_hd__tapvpwrvgnd_1
XTAP_TAPCELL_ROW_38_766 VGND VPWR sky130_fd_sc_hd__tapvpwrvgnd_1
XFILLER_55_579 VGND VGND VPWR VPWR sky130_fd_sc_hd__decap_3
XFILLER_82_365 VGND VGND VPWR VPWR sky130_fd_sc_hd__decap_3
XPHY_EDGE_ROW_118_Right_118 VGND VGND VPWR VPWR sky130_fd_sc_hd__decap_3
XFILLER_42_218 VGND VGND VPWR VPWR sky130_fd_sc_hd__decap_3
XFILLER_35_281 VGND VGND VPWR VPWR sky130_fd_sc_hd__decap_3
XFILLER_23_421 VGND VGND VPWR VPWR sky130_fd_sc_hd__decap_3
X_6827_ _6967_/CLK _6827_/D VGND VGND VPWR VPWR _6827_/Q sky130_fd_sc_hd__dfxtp_2
XFILLER_50_262 VGND VGND VPWR VPWR sky130_fd_sc_hd__decap_3
XFILLER_23_476 VGND VGND VPWR VPWR sky130_fd_sc_hd__fill_2
XFILLER_11_638 VGND VGND VPWR VPWR sky130_fd_sc_hd__decap_3
X_6758_ _6960_/CLK _6758_/D VGND VGND VPWR VPWR _6758_/Q sky130_fd_sc_hd__dfxtp_2
XFILLER_50_295 VGND VGND VPWR VPWR sky130_fd_sc_hd__decap_3
XFILLER_7_609 VGND VGND VPWR VPWR sky130_fd_sc_hd__decap_3
XTAP_TAPCELL_ROW_98_1543 VGND VPWR sky130_fd_sc_hd__tapvpwrvgnd_1
XFILLER_12_33 VGND VGND VPWR VPWR sky130_fd_sc_hd__decap_3
X_6689_ _6926_/CLK _6689_/D VGND VGND VPWR VPWR _6689_/Q sky130_fd_sc_hd__dfxtp_2
XFILLER_109_537 VGND VGND VPWR VPWR sky130_fd_sc_hd__decap_3
XFILLER_88_26 VGND VGND VPWR VPWR sky130_fd_sc_hd__fill_2
XFILLER_2_303 VGND VGND VPWR VPWR sky130_fd_sc_hd__fill_1
XFILLER_117_570 VGND VGND VPWR VPWR sky130_fd_sc_hd__decap_3
XFILLER_105_721 VGND VGND VPWR VPWR sky130_fd_sc_hd__decap_3
XFILLER_105_732 VGND VGND VPWR VPWR sky130_fd_sc_hd__decap_3
XFILLER_104_220 VGND VGND VPWR VPWR sky130_fd_sc_hd__decap_3
XFILLER_104_231 VGND VGND VPWR VPWR sky130_fd_sc_hd__decap_3
XFILLER_78_616 VGND VGND VPWR VPWR sky130_fd_sc_hd__decap_3
XFILLER_120_713 VGND VGND VPWR VPWR sky130_fd_sc_hd__decap_3
XFILLER_77_159 VGND VGND VPWR VPWR sky130_fd_sc_hd__decap_3
XFILLER_58_340 VGND VGND VPWR VPWR sky130_fd_sc_hd__decap_3
XFILLER_86_660 VGND VGND VPWR VPWR sky130_fd_sc_hd__decap_3
XFILLER_19_727 VGND VGND VPWR VPWR sky130_fd_sc_hd__fill_1
XFILLER_86_693 VGND VGND VPWR VPWR sky130_fd_sc_hd__decap_3
XFILLER_73_321 VGND VGND VPWR VPWR sky130_fd_sc_hd__decap_3
XFILLER_100_492 VGND VGND VPWR VPWR sky130_fd_sc_hd__decap_3
XFILLER_37_74 VGND VGND VPWR VPWR sky130_fd_sc_hd__fill_1
XFILLER_34_719 VGND VGND VPWR VPWR sky130_fd_sc_hd__decap_3
XFILLER_61_505 VGND VGND VPWR VPWR sky130_fd_sc_hd__decap_3
XTAP_TAPCELL_ROW_107_1661 VGND VPWR sky130_fd_sc_hd__tapvpwrvgnd_1
XFILLER_26_270 VGND VGND VPWR VPWR sky130_fd_sc_hd__decap_3
XFILLER_14_410 VGND VGND VPWR VPWR sky130_fd_sc_hd__decap_3
XFILLER_14_421 VGND VGND VPWR VPWR sky130_fd_sc_hd__decap_3
XFILLER_26_292 VGND VGND VPWR VPWR sky130_fd_sc_hd__decap_3
XFILLER_14_454 VGND VGND VPWR VPWR sky130_fd_sc_hd__fill_1
XFILLER_41_251 VGND VGND VPWR VPWR sky130_fd_sc_hd__decap_3
XFILLER_41_284 VGND VGND VPWR VPWR sky130_fd_sc_hd__decap_3
XFILLER_10_660 VGND VGND VPWR VPWR sky130_fd_sc_hd__decap_3
XFILLER_6_631 VGND VGND VPWR VPWR sky130_fd_sc_hd__decap_3
XFILLER_10_693 VGND VGND VPWR VPWR sky130_fd_sc_hd__decap_3
XTAP_TAPCELL_ROW_58_1015 VGND VPWR sky130_fd_sc_hd__tapvpwrvgnd_1
XTAP_TAPCELL_ROW_58_1026 VGND VPWR sky130_fd_sc_hd__tapvpwrvgnd_1
XFILLER_6_675 VGND VGND VPWR VPWR sky130_fd_sc_hd__decap_3
XFILLER_115_529 VGND VGND VPWR VPWR sky130_fd_sc_hd__decap_3
XFILLER_108_581 VGND VGND VPWR VPWR sky130_fd_sc_hd__decap_3
XFILLER_108_592 VGND VGND VPWR VPWR sky130_fd_sc_hd__decap_3
XFILLER_69_638 VGND VGND VPWR VPWR sky130_fd_sc_hd__decap_3
XFILLER_123_584 VGND VGND VPWR VPWR sky130_fd_sc_hd__decap_3
XFILLER_111_724 VGND VGND VPWR VPWR sky130_fd_sc_hd__decap_3
XFILLER_78_81 VGND VGND VPWR VPWR sky130_fd_sc_hd__decap_3
XFILLER_123_595 VGND VGND VPWR VPWR sky130_fd_sc_hd__fill_2
XFILLER_110_212 VGND VGND VPWR VPWR sky130_fd_sc_hd__decap_3
X_4040_ _4608_/B _4040_/B VGND VGND VPWR VPWR _4040_/Y sky130_fd_sc_hd__nor2_2
XFILLER_96_468 VGND VGND VPWR VPWR sky130_fd_sc_hd__decap_3
XFILLER_110_245 VGND VGND VPWR VPWR sky130_fd_sc_hd__decap_3
XFILLER_84_619 VGND VGND VPWR VPWR sky130_fd_sc_hd__decap_3
XFILLER_110_256 VGND VGND VPWR VPWR sky130_fd_sc_hd__decap_3
XFILLER_77_671 VGND VGND VPWR VPWR sky130_fd_sc_hd__fill_1
XFILLER_49_362 VGND VGND VPWR VPWR sky130_fd_sc_hd__decap_3
XFILLER_77_682 VGND VGND VPWR VPWR sky130_fd_sc_hd__decap_3
XFILLER_49_384 VGND VGND VPWR VPWR sky130_fd_sc_hd__fill_1
XFILLER_76_192 VGND VGND VPWR VPWR sky130_fd_sc_hd__decap_3
XFILLER_92_663 VGND VGND VPWR VPWR sky130_fd_sc_hd__decap_3
XFILLER_91_140 VGND VGND VPWR VPWR sky130_fd_sc_hd__decap_3
XFILLER_64_354 VGND VGND VPWR VPWR sky130_fd_sc_hd__fill_1
XTAP_TAPCELL_ROW_69_1166 VGND VPWR sky130_fd_sc_hd__tapvpwrvgnd_1
XFILLER_64_365 VGND VGND VPWR VPWR sky130_fd_sc_hd__decap_3
XFILLER_52_516 VGND VGND VPWR VPWR sky130_fd_sc_hd__decap_3
XTAP_TAPCELL_ROW_35_725 VGND VPWR sky130_fd_sc_hd__tapvpwrvgnd_1
XFILLER_92_696 VGND VGND VPWR VPWR sky130_fd_sc_hd__decap_3
XFILLER_91_184 VGND VGND VPWR VPWR sky130_fd_sc_hd__decap_3
XFILLER_24_229 VGND VGND VPWR VPWR sky130_fd_sc_hd__decap_3
X_4942_ _6995_/Q _4960_/B _4677_/B _5667_/A VGND VGND VPWR VPWR _4943_/B sky130_fd_sc_hd__o211ai_2
XTAP_TAPCELL_ROW_82_1333 VGND VPWR sky130_fd_sc_hd__tapvpwrvgnd_1
XFILLER_32_240 VGND VGND VPWR VPWR sky130_fd_sc_hd__decap_3
X_4873_ _4764_/B _4111_/B _4845_/A _5101_/A VGND VGND VPWR VPWR _4873_/X sky130_fd_sc_hd__o22a_2
XFILLER_60_571 VGND VGND VPWR VPWR sky130_fd_sc_hd__decap_3
XTAP_TAPCELL_ROW_15_460 VGND VPWR sky130_fd_sc_hd__tapvpwrvgnd_1
X_6612_ _6612_/A VGND VGND VPWR VPWR _6612_/Y sky130_fd_sc_hd__inv_2
X_3824_ _6965_/Q _3906_/A2 _3898_/B1 _6953_/Q _3823_/X VGND VGND VPWR VPWR _3824_/X
+ sky130_fd_sc_hd__a221o_2
X_3755_ _6934_/Q _3898_/A2 _3759_/B1 _6886_/Q VGND VGND VPWR VPWR _3755_/X sky130_fd_sc_hd__a22o_2
X_6543_ _6642_/A VGND VGND VPWR VPWR _6543_/Y sky130_fd_sc_hd__inv_2
XFILLER_118_312 VGND VGND VPWR VPWR sky130_fd_sc_hd__decap_3
XFILLER_118_323 VGND VGND VPWR VPWR sky130_fd_sc_hd__decap_3
X_6474_ _6638_/A VGND VGND VPWR VPWR _6474_/Y sky130_fd_sc_hd__inv_2
XFILLER_106_529 VGND VGND VPWR VPWR sky130_fd_sc_hd__decap_3
XPHY_EDGE_ROW_12_Right_12 VGND VGND VPWR VPWR sky130_fd_sc_hd__decap_3
X_5425_ _5425_/A0 _3993_/X _5429_/S VGND VGND VPWR VPWR _7121_/D sky130_fd_sc_hd__mux2_2
X_5356_ _5356_/A0 _3993_/X _7412_/A VGND VGND VPWR VPWR _7153_/D sky130_fd_sc_hd__mux2_2
XTAP_TAPCELL_ROW_93_1473 VGND VPWR sky130_fd_sc_hd__tapvpwrvgnd_1
XFILLER_114_551 VGND VGND VPWR VPWR sky130_fd_sc_hd__decap_3
XFILLER_87_402 VGND VGND VPWR VPWR sky130_fd_sc_hd__decap_3
XFILLER_99_262 VGND VGND VPWR VPWR sky130_fd_sc_hd__decap_3
XFILLER_102_713 VGND VGND VPWR VPWR sky130_fd_sc_hd__decap_3
X_4307_ _7224_/Q _4307_/A2 _4520_/S _7037_/Q VGND VGND VPWR VPWR _4307_/X sky130_fd_sc_hd__a22o_2
XFILLER_99_284 VGND VGND VPWR VPWR sky130_fd_sc_hd__decap_3
XFILLER_114_584 VGND VGND VPWR VPWR sky130_fd_sc_hd__decap_3
XFILLER_114_595 VGND VGND VPWR VPWR sky130_fd_sc_hd__decap_3
XFILLER_101_234 VGND VGND VPWR VPWR sky130_fd_sc_hd__decap_3
X_4238_ _7067_/Q _4305_/B _4460_/A _4237_/X VGND VGND VPWR VPWR _4629_/B sky130_fd_sc_hd__o211ai_2
X_7026_ _7372_/CLK _7026_/D _6306_/Y VGND VGND VPWR VPWR _7026_/Q sky130_fd_sc_hd__dfrtp_2
XFILLER_59_159 VGND VGND VPWR VPWR sky130_fd_sc_hd__fill_1
XFILLER_114_24 VGND VGND VPWR VPWR sky130_fd_sc_hd__decap_3
XFILLER_68_660 VGND VGND VPWR VPWR sky130_fd_sc_hd__decap_3
XFILLER_114_35 VGND VGND VPWR VPWR sky130_fd_sc_hd__decap_3
XFILLER_101_289 VGND VGND VPWR VPWR sky130_fd_sc_hd__decap_3
XFILLER_68_693 VGND VGND VPWR VPWR sky130_fd_sc_hd__decap_3
XFILLER_28_524 VGND VGND VPWR VPWR sky130_fd_sc_hd__decap_3
X_4169_ _4165_/X _4168_/X _4425_/A VGND VGND VPWR VPWR _4202_/A sky130_fd_sc_hd__o21a_2
XFILLER_114_68 VGND VGND VPWR VPWR sky130_fd_sc_hd__decap_3
XFILLER_95_490 VGND VGND VPWR VPWR sky130_fd_sc_hd__fill_2
XFILLER_83_641 VGND VGND VPWR VPWR sky130_fd_sc_hd__decap_3
XFILLER_67_192 VGND VGND VPWR VPWR sky130_fd_sc_hd__decap_3
XFILLER_28_568 VGND VGND VPWR VPWR sky130_fd_sc_hd__decap_3
XPHY_EDGE_ROW_21_Right_21 VGND VGND VPWR VPWR sky130_fd_sc_hd__decap_3
XFILLER_16_719 VGND VGND VPWR VPWR sky130_fd_sc_hd__decap_3
XFILLER_83_685 VGND VGND VPWR VPWR sky130_fd_sc_hd__decap_3
XFILLER_70_302 VGND VGND VPWR VPWR sky130_fd_sc_hd__decap_3
XFILLER_70_324 VGND VGND VPWR VPWR sky130_fd_sc_hd__decap_3
XFILLER_43_538 VGND VGND VPWR VPWR sky130_fd_sc_hd__decap_3
XFILLER_70_357 VGND VGND VPWR VPWR sky130_fd_sc_hd__decap_3
XFILLER_70_368 VGND VGND VPWR VPWR sky130_fd_sc_hd__decap_3
XFILLER_23_262 VGND VGND VPWR VPWR sky130_fd_sc_hd__decap_3
XFILLER_11_402 VGND VGND VPWR VPWR sky130_fd_sc_hd__decap_3
XFILLER_23_284 VGND VGND VPWR VPWR sky130_fd_sc_hd__decap_3
XFILLER_11_435 VGND VGND VPWR VPWR sky130_fd_sc_hd__decap_3
XTAP_TAPCELL_ROW_102_1591 VGND VPWR sky130_fd_sc_hd__tapvpwrvgnd_1
XFILLER_11_457 VGND VGND VPWR VPWR sky130_fd_sc_hd__decap_3
XFILLER_109_301 VGND VGND VPWR VPWR sky130_fd_sc_hd__decap_3
XFILLER_23_87 VGND VGND VPWR VPWR sky130_fd_sc_hd__fill_1
XFILLER_7_439 VGND VGND VPWR VPWR sky130_fd_sc_hd__decap_3
XPHY_EDGE_ROW_30_Right_30 VGND VGND VPWR VPWR sky130_fd_sc_hd__decap_3
XFILLER_3_612 VGND VGND VPWR VPWR sky130_fd_sc_hd__decap_3
XFILLER_3_623 VGND VGND VPWR VPWR sky130_fd_sc_hd__decap_3
XFILLER_3_656 VGND VGND VPWR VPWR sky130_fd_sc_hd__decap_3
XFILLER_105_540 VGND VGND VPWR VPWR sky130_fd_sc_hd__decap_3
XFILLER_78_402 VGND VGND VPWR VPWR sky130_fd_sc_hd__decap_3
XFILLER_105_573 VGND VGND VPWR VPWR sky130_fd_sc_hd__decap_3
XFILLER_120_510 VGND VGND VPWR VPWR sky130_fd_sc_hd__decap_3
XFILLER_120_554 VGND VGND VPWR VPWR sky130_fd_sc_hd__decap_3
XFILLER_59_671 VGND VGND VPWR VPWR sky130_fd_sc_hd__fill_1
XFILLER_59_682 VGND VGND VPWR VPWR sky130_fd_sc_hd__decap_3
XFILLER_120_587 VGND VGND VPWR VPWR sky130_fd_sc_hd__fill_1
XFILLER_65_129 VGND VGND VPWR VPWR sky130_fd_sc_hd__fill_2
XFILLER_120_598 VGND VGND VPWR VPWR sky130_fd_sc_hd__decap_3
XFILLER_93_449 VGND VGND VPWR VPWR sky130_fd_sc_hd__decap_3
XFILLER_58_170 VGND VGND VPWR VPWR sky130_fd_sc_hd__decap_3
XFILLER_0_14 VGND VGND VPWR VPWR sky130_fd_sc_hd__decap_3
XFILLER_46_321 VGND VGND VPWR VPWR sky130_fd_sc_hd__decap_3
XFILLER_0_47 VGND VGND VPWR VPWR sky130_fd_sc_hd__fill_1
XFILLER_74_663 VGND VGND VPWR VPWR sky130_fd_sc_hd__decap_3
XFILLER_19_579 VGND VGND VPWR VPWR sky130_fd_sc_hd__decap_3
XFILLER_34_505 VGND VGND VPWR VPWR sky130_fd_sc_hd__decap_3
XFILLER_74_696 VGND VGND VPWR VPWR sky130_fd_sc_hd__decap_3
XFILLER_46_398 VGND VGND VPWR VPWR sky130_fd_sc_hd__fill_1
XFILLER_61_324 VGND VGND VPWR VPWR sky130_fd_sc_hd__decap_3
XFILLER_34_549 VGND VGND VPWR VPWR sky130_fd_sc_hd__decap_3
XFILLER_27_590 VGND VGND VPWR VPWR sky130_fd_sc_hd__decap_3
XFILLER_61_346 VGND VGND VPWR VPWR sky130_fd_sc_hd__fill_2
XFILLER_14_251 VGND VGND VPWR VPWR sky130_fd_sc_hd__fill_1
XFILLER_42_571 VGND VGND VPWR VPWR sky130_fd_sc_hd__decap_3
XFILLER_30_722 VGND VGND VPWR VPWR sky130_fd_sc_hd__decap_3
XTAP_TAPCELL_ROW_64_1096 VGND VPWR sky130_fd_sc_hd__tapvpwrvgnd_1
XFILLER_14_295 VGND VGND VPWR VPWR sky130_fd_sc_hd__decap_3
XFILLER_80_60 VGND VGND VPWR VPWR sky130_fd_sc_hd__fill_2
XFILLER_80_82 VGND VGND VPWR VPWR sky130_fd_sc_hd__fill_2
XTAP_TAPCELL_ROW_40_783 VGND VPWR sky130_fd_sc_hd__tapvpwrvgnd_1
X_3540_ _3502_/A _3502_/B _3485_/C VGND VGND VPWR VPWR _3540_/X sky130_fd_sc_hd__o21a_2
Xhold907 _6718_/Q VGND VGND VPWR VPWR hold907/X sky130_fd_sc_hd__dlygate4sd3_1
XFILLER_6_450 VGND VGND VPWR VPWR sky130_fd_sc_hd__decap_3
Xhold918 _6713_/Q VGND VGND VPWR VPWR hold918/X sky130_fd_sc_hd__dlygate4sd3_1
X_3471_ _3545_/A _3545_/B VGND VGND VPWR VPWR _3505_/A sky130_fd_sc_hd__and2b_2
Xhold929 _7032_/Q VGND VGND VPWR VPWR _5591_/A sky130_fd_sc_hd__dlygate4sd3_1
XFILLER_115_326 VGND VGND VPWR VPWR sky130_fd_sc_hd__decap_3
XFILLER_6_494 VGND VGND VPWR VPWR sky130_fd_sc_hd__decap_3
XFILLER_115_359 VGND VGND VPWR VPWR sky130_fd_sc_hd__decap_3
XFILLER_43_3 VGND VGND VPWR VPWR sky130_fd_sc_hd__fill_1
XFILLER_97_700 VGND VGND VPWR VPWR sky130_fd_sc_hd__decap_3
XFILLER_69_402 VGND VGND VPWR VPWR sky130_fd_sc_hd__decap_3
XFILLER_111_543 VGND VGND VPWR VPWR sky130_fd_sc_hd__decap_3
XFILLER_96_243 VGND VGND VPWR VPWR sky130_fd_sc_hd__decap_3
XFILLER_57_608 VGND VGND VPWR VPWR sky130_fd_sc_hd__decap_3
X_5072_ _5072_/A _5072_/B _5072_/C VGND VGND VPWR VPWR _5075_/B sky130_fd_sc_hd__and3_2
XFILLER_111_576 VGND VGND VPWR VPWR sky130_fd_sc_hd__decap_3
XFILLER_96_287 VGND VGND VPWR VPWR sky130_fd_sc_hd__decap_3
XFILLER_37_310 VGND VGND VPWR VPWR sky130_fd_sc_hd__decap_3
XFILLER_49_181 VGND VGND VPWR VPWR sky130_fd_sc_hd__fill_2
XFILLER_65_641 VGND VGND VPWR VPWR sky130_fd_sc_hd__decap_3
XFILLER_37_343 VGND VGND VPWR VPWR sky130_fd_sc_hd__decap_3
XFILLER_25_505 VGND VGND VPWR VPWR sky130_fd_sc_hd__decap_3
XFILLER_65_685 VGND VGND VPWR VPWR sky130_fd_sc_hd__decap_3
XFILLER_37_376 VGND VGND VPWR VPWR sky130_fd_sc_hd__decap_3
XFILLER_92_471 VGND VGND VPWR VPWR sky130_fd_sc_hd__decap_3
XFILLER_92_482 VGND VGND VPWR VPWR sky130_fd_sc_hd__fill_1
XFILLER_80_622 VGND VGND VPWR VPWR sky130_fd_sc_hd__decap_3
XTAP_TAPCELL_ROW_48_894 VGND VPWR sky130_fd_sc_hd__tapvpwrvgnd_1
XFILLER_52_346 VGND VGND VPWR VPWR sky130_fd_sc_hd__decap_3
XFILLER_80_666 VGND VGND VPWR VPWR sky130_fd_sc_hd__decap_3
XFILLER_52_368 VGND VGND VPWR VPWR sky130_fd_sc_hd__decap_3
X_4925_ _4764_/B _4158_/A _4920_/A _5101_/A _4924_/X VGND VGND VPWR VPWR _4925_/X
+ sky130_fd_sc_hd__o221a_2
XFILLER_40_519 VGND VGND VPWR VPWR sky130_fd_sc_hd__decap_3
XFILLER_21_700 VGND VGND VPWR VPWR sky130_fd_sc_hd__decap_3
XFILLER_80_699 VGND VGND VPWR VPWR sky130_fd_sc_hd__fill_1
XFILLER_100_26 VGND VGND VPWR VPWR sky130_fd_sc_hd__fill_2
XFILLER_33_593 VGND VGND VPWR VPWR sky130_fd_sc_hd__decap_3
XFILLER_20_221 VGND VGND VPWR VPWR sky130_fd_sc_hd__fill_1
XFILLER_100_59 VGND VGND VPWR VPWR sky130_fd_sc_hd__decap_3
X_3807_ _6703_/Q _3925_/A2 _3871_/B1 _6881_/Q VGND VGND VPWR VPWR _3807_/X sky130_fd_sc_hd__a22o_2
XFILLER_20_265 VGND VGND VPWR VPWR sky130_fd_sc_hd__decap_3
X_4787_ _4787_/A _4787_/B VGND VGND VPWR VPWR _4787_/Y sky130_fd_sc_hd__xnor2_2
XFILLER_119_632 VGND VGND VPWR VPWR sky130_fd_sc_hd__decap_3
XTAP_TAPCELL_ROW_95_1502 VGND VPWR sky130_fd_sc_hd__tapvpwrvgnd_1
X_6526_ _6558_/A VGND VGND VPWR VPWR _6526_/Y sky130_fd_sc_hd__inv_2
XFILLER_119_665 VGND VGND VPWR VPWR sky130_fd_sc_hd__decap_3
X_3738_ _6740_/Q _3889_/A2 _3925_/A2 _6734_/Q _3737_/X VGND VGND VPWR VPWR _3738_/X
+ sky130_fd_sc_hd__a221o_2
XFILLER_119_676 VGND VGND VPWR VPWR sky130_fd_sc_hd__decap_3
XFILLER_109_24 VGND VGND VPWR VPWR sky130_fd_sc_hd__decap_3
XFILLER_114_9 VGND VGND VPWR VPWR sky130_fd_sc_hd__decap_3
XFILLER_106_304 VGND VGND VPWR VPWR sky130_fd_sc_hd__decap_3
XFILLER_106_315 VGND VGND VPWR VPWR sky130_fd_sc_hd__decap_3
XFILLER_109_57 VGND VGND VPWR VPWR sky130_fd_sc_hd__fill_2
X_6457_ _6649_/A VGND VGND VPWR VPWR _6457_/Y sky130_fd_sc_hd__inv_2
X_3669_ _6807_/Q _3759_/A2 _3767_/A2 _6717_/Q _3668_/X VGND VGND VPWR VPWR _3669_/X
+ sky130_fd_sc_hd__a221o_2
XFILLER_106_337 VGND VGND VPWR VPWR sky130_fd_sc_hd__decap_3
XFILLER_69_39 VGND VGND VPWR VPWR sky130_fd_sc_hd__decap_3
X_6388_ _6612_/A VGND VGND VPWR VPWR _6388_/Y sky130_fd_sc_hd__inv_2
XFILLER_88_722 VGND VGND VPWR VPWR sky130_fd_sc_hd__decap_3
XFILLER_0_659 VGND VGND VPWR VPWR sky130_fd_sc_hd__decap_3
XFILLER_102_554 VGND VGND VPWR VPWR sky130_fd_sc_hd__decap_3
XFILLER_87_254 VGND VGND VPWR VPWR sky130_fd_sc_hd__decap_3
XFILLER_75_405 VGND VGND VPWR VPWR sky130_fd_sc_hd__decap_3
XFILLER_102_587 VGND VGND VPWR VPWR sky130_fd_sc_hd__fill_1
XFILLER_102_598 VGND VGND VPWR VPWR sky130_fd_sc_hd__decap_3
X_7009_ _7371_/CLK _7009_/D _6289_/Y VGND VGND VPWR VPWR _7009_/Q sky130_fd_sc_hd__dfrtp_2
XFILLER_28_321 VGND VGND VPWR VPWR sky130_fd_sc_hd__decap_3
XFILLER_18_32 VGND VGND VPWR VPWR sky130_fd_sc_hd__fill_1
XFILLER_56_663 VGND VGND VPWR VPWR sky130_fd_sc_hd__decap_3
XFILLER_28_354 VGND VGND VPWR VPWR sky130_fd_sc_hd__decap_3
XFILLER_28_365 VGND VGND VPWR VPWR sky130_fd_sc_hd__decap_3
XFILLER_56_696 VGND VGND VPWR VPWR sky130_fd_sc_hd__decap_3
XFILLER_28_398 VGND VGND VPWR VPWR sky130_fd_sc_hd__decap_3
XFILLER_71_644 VGND VGND VPWR VPWR sky130_fd_sc_hd__decap_3
XFILLER_16_549 VGND VGND VPWR VPWR sky130_fd_sc_hd__decap_3
XTAP_TAPCELL_ROW_104_1620 VGND VPWR sky130_fd_sc_hd__tapvpwrvgnd_1
XFILLER_43_346 VGND VGND VPWR VPWR sky130_fd_sc_hd__fill_2
XFILLER_31_508 VGND VGND VPWR VPWR sky130_fd_sc_hd__decap_3
XFILLER_71_688 VGND VGND VPWR VPWR sky130_fd_sc_hd__decap_3
XFILLER_70_165 VGND VGND VPWR VPWR sky130_fd_sc_hd__decap_3
XFILLER_12_722 VGND VGND VPWR VPWR sky130_fd_sc_hd__decap_3
XTAP_TAPCELL_ROW_26_599 VGND VPWR sky130_fd_sc_hd__tapvpwrvgnd_1
XFILLER_8_704 VGND VGND VPWR VPWR sky130_fd_sc_hd__decap_3
XFILLER_7_214 VGND VGND VPWR VPWR sky130_fd_sc_hd__decap_3
XFILLER_50_41 VGND VGND VPWR VPWR sky130_fd_sc_hd__decap_3
XFILLER_11_298 VGND VGND VPWR VPWR sky130_fd_sc_hd__decap_3
XFILLER_7_269 VGND VGND VPWR VPWR sky130_fd_sc_hd__decap_3
XFILLER_50_74 VGND VGND VPWR VPWR sky130_fd_sc_hd__fill_2
XFILLER_50_85 VGND VGND VPWR VPWR sky130_fd_sc_hd__decap_3
XFILLER_3_431 VGND VGND VPWR VPWR sky130_fd_sc_hd__decap_3
XTAP_TAPCELL_ROW_115_1760 VGND VPWR sky130_fd_sc_hd__tapvpwrvgnd_1
XFILLER_79_700 VGND VGND VPWR VPWR sky130_fd_sc_hd__decap_3
XFILLER_3_464 VGND VGND VPWR VPWR sky130_fd_sc_hd__decap_3
XFILLER_112_318 VGND VGND VPWR VPWR sky130_fd_sc_hd__decap_3
XFILLER_105_370 VGND VGND VPWR VPWR sky130_fd_sc_hd__decap_3
XFILLER_78_221 VGND VGND VPWR VPWR sky130_fd_sc_hd__decap_3
XFILLER_59_94 VGND VGND VPWR VPWR sky130_fd_sc_hd__fill_1
XFILLER_39_608 VGND VGND VPWR VPWR sky130_fd_sc_hd__decap_3
XFILLER_66_405 VGND VGND VPWR VPWR sky130_fd_sc_hd__fill_2
XFILLER_94_725 VGND VGND VPWR VPWR sky130_fd_sc_hd__decap_3
XFILLER_66_416 VGND VGND VPWR VPWR sky130_fd_sc_hd__decap_3
XFILLER_19_310 VGND VGND VPWR VPWR sky130_fd_sc_hd__decap_3
XFILLER_120_395 VGND VGND VPWR VPWR sky130_fd_sc_hd__decap_3
XFILLER_59_490 VGND VGND VPWR VPWR sky130_fd_sc_hd__decap_3
XFILLER_47_641 VGND VGND VPWR VPWR sky130_fd_sc_hd__decap_3
XFILLER_19_332 VGND VGND VPWR VPWR sky130_fd_sc_hd__decap_3
XFILLER_75_60 VGND VGND VPWR VPWR sky130_fd_sc_hd__decap_3
XFILLER_93_279 VGND VGND VPWR VPWR sky130_fd_sc_hd__fill_1
XFILLER_75_82 VGND VGND VPWR VPWR sky130_fd_sc_hd__decap_3
XFILLER_74_460 VGND VGND VPWR VPWR sky130_fd_sc_hd__decap_3
XFILLER_62_611 VGND VGND VPWR VPWR sky130_fd_sc_hd__decap_3
XFILLER_47_685 VGND VGND VPWR VPWR sky130_fd_sc_hd__decap_3
XTAP_TAPCELL_ROW_66_1125 VGND VPWR sky130_fd_sc_hd__tapvpwrvgnd_1
XFILLER_74_493 VGND VGND VPWR VPWR sky130_fd_sc_hd__fill_2
XFILLER_61_110 VGND VGND VPWR VPWR sky130_fd_sc_hd__fill_2
XFILLER_34_324 VGND VGND VPWR VPWR sky130_fd_sc_hd__decap_3
XFILLER_61_121 VGND VGND VPWR VPWR sky130_fd_sc_hd__fill_2
XFILLER_34_346 VGND VGND VPWR VPWR sky130_fd_sc_hd__decap_3
XTAP_TAPCELL_ROW_45_853 VGND VPWR sky130_fd_sc_hd__tapvpwrvgnd_1
XFILLER_62_666 VGND VGND VPWR VPWR sky130_fd_sc_hd__decap_3
XFILLER_34_368 VGND VGND VPWR VPWR sky130_fd_sc_hd__fill_1
XFILLER_62_699 VGND VGND VPWR VPWR sky130_fd_sc_hd__fill_1
XFILLER_15_582 VGND VGND VPWR VPWR sky130_fd_sc_hd__decap_3
X_4710_ _7004_/Q _4801_/A VGND VGND VPWR VPWR _4775_/A sky130_fd_sc_hd__and2_2
X_5690_ _7351_/Q hold922/X _5708_/S VGND VGND VPWR VPWR _6695_/D sky130_fd_sc_hd__mux2_2
X_4641_ _4920_/A _4379_/B _4640_/Y _4158_/A VGND VGND VPWR VPWR _4903_/B sky130_fd_sc_hd__o31a_2
X_7360_ _7360_/CLK _7360_/D _6640_/Y VGND VGND VPWR VPWR _7360_/Q sky130_fd_sc_hd__dfrtp_2
XFILLER_116_613 VGND VGND VPWR VPWR sky130_fd_sc_hd__decap_3
X_6311_ _6602_/A VGND VGND VPWR VPWR _6311_/Y sky130_fd_sc_hd__inv_2
Xhold704 _6972_/Q VGND VGND VPWR VPWR _6972_/D sky130_fd_sc_hd__dlygate4sd3_1
X_3523_ _3505_/A _3458_/Y _3505_/B _3506_/Y _3508_/A VGND VGND VPWR VPWR _3620_/A
+ sky130_fd_sc_hd__o311a_4
Xhold715 _6915_/Q VGND VGND VPWR VPWR _6915_/D sky130_fd_sc_hd__dlygate4sd3_1
Xhold726 _6735_/Q VGND VGND VPWR VPWR _6735_/D sky130_fd_sc_hd__dlygate4sd3_1
X_7291_ _7355_/CLK _7291_/D _6571_/Y VGND VGND VPWR VPWR _7291_/Q sky130_fd_sc_hd__dfrtp_2
XTAP_TAPCELL_ROW_77_1265 VGND VPWR sky130_fd_sc_hd__tapvpwrvgnd_1
Xhold737 _6781_/Q VGND VGND VPWR VPWR _6781_/D sky130_fd_sc_hd__dlygate4sd3_1
XFILLER_116_657 VGND VGND VPWR VPWR sky130_fd_sc_hd__decap_3
Xhold748 _6795_/Q VGND VGND VPWR VPWR _6795_/D sky130_fd_sc_hd__dlygate4sd3_1
XFILLER_89_508 VGND VGND VPWR VPWR sky130_fd_sc_hd__decap_3
X_3454_ _7186_/Q _3989_/S _4532_/S _7031_/Q _3453_/X VGND VGND VPWR VPWR _3454_/X
+ sky130_fd_sc_hd__a221o_2
Xhold759 _6886_/Q VGND VGND VPWR VPWR _6886_/D sky130_fd_sc_hd__dlygate4sd3_1
XFILLER_115_167 VGND VGND VPWR VPWR sky130_fd_sc_hd__fill_1
XFILLER_103_318 VGND VGND VPWR VPWR sky130_fd_sc_hd__decap_3
XTAP_TAPCELL_ROW_90_1432 VGND VPWR sky130_fd_sc_hd__tapvpwrvgnd_1
XFILLER_115_189 VGND VGND VPWR VPWR sky130_fd_sc_hd__fill_2
XTAP_TAPCELL_ROW_90_1443 VGND VPWR sky130_fd_sc_hd__tapvpwrvgnd_1
X_3385_ _6983_/Q _5130_/A VGND VGND VPWR VPWR _3385_/Y sky130_fd_sc_hd__nor2_2
XFILLER_69_243 VGND VGND VPWR VPWR sky130_fd_sc_hd__decap_3
XFILLER_111_340 VGND VGND VPWR VPWR sky130_fd_sc_hd__decap_3
X_5124_ _3746_/B _3900_/Y _4677_/B VGND VGND VPWR VPWR _5125_/B sky130_fd_sc_hd__a21o_2
XFILLER_85_703 VGND VGND VPWR VPWR sky130_fd_sc_hd__decap_3
XFILLER_97_585 VGND VGND VPWR VPWR sky130_fd_sc_hd__decap_3
XFILLER_111_362 VGND VGND VPWR VPWR sky130_fd_sc_hd__decap_3
XFILLER_69_287 VGND VGND VPWR VPWR sky130_fd_sc_hd__decap_3
X_5055_ _4811_/C _5049_/X _5053_/Y _5054_/Y _4369_/A VGND VGND VPWR VPWR _5055_/X
+ sky130_fd_sc_hd__a221o_2
XFILLER_84_235 VGND VGND VPWR VPWR sky130_fd_sc_hd__decap_3
XFILLER_57_449 VGND VGND VPWR VPWR sky130_fd_sc_hd__decap_3
XFILLER_38_663 VGND VGND VPWR VPWR sky130_fd_sc_hd__decap_3
XFILLER_72_419 VGND VGND VPWR VPWR sky130_fd_sc_hd__fill_1
XFILLER_53_600 VGND VGND VPWR VPWR sky130_fd_sc_hd__decap_3
XFILLER_38_696 VGND VGND VPWR VPWR sky130_fd_sc_hd__decap_3
XPHY_EDGE_ROW_9_Left_133 VGND VGND VPWR VPWR sky130_fd_sc_hd__decap_3
XFILLER_53_644 VGND VGND VPWR VPWR sky130_fd_sc_hd__decap_3
XFILLER_111_36 VGND VGND VPWR VPWR sky130_fd_sc_hd__decap_3
XFILLER_80_452 VGND VGND VPWR VPWR sky130_fd_sc_hd__decap_3
XFILLER_25_368 VGND VGND VPWR VPWR sky130_fd_sc_hd__decap_3
XFILLER_80_474 VGND VGND VPWR VPWR sky130_fd_sc_hd__fill_2
XFILLER_53_688 VGND VGND VPWR VPWR sky130_fd_sc_hd__decap_3
XFILLER_71_18 VGND VGND VPWR VPWR sky130_fd_sc_hd__decap_3
XFILLER_111_69 VGND VGND VPWR VPWR sky130_fd_sc_hd__fill_1
X_4908_ _4908_/A _4908_/B VGND VGND VPWR VPWR _4909_/C sky130_fd_sc_hd__nor2_2
XTAP_TAPCELL_ROW_23_569 VGND VPWR sky130_fd_sc_hd__tapvpwrvgnd_1
XFILLER_21_574 VGND VGND VPWR VPWR sky130_fd_sc_hd__decap_3
X_4839_ _4916_/A _4916_/B _4634_/Y VGND VGND VPWR VPWR _4903_/C sky130_fd_sc_hd__a21o_2
XFILLER_5_718 VGND VGND VPWR VPWR sky130_fd_sc_hd__decap_3
XFILLER_5_729 VGND VGND VPWR VPWR sky130_fd_sc_hd__decap_3
XFILLER_4_206 VGND VGND VPWR VPWR sky130_fd_sc_hd__decap_3
XFILLER_119_484 VGND VGND VPWR VPWR sky130_fd_sc_hd__decap_3
X_6509_ _6644_/A VGND VGND VPWR VPWR _6509_/Y sky130_fd_sc_hd__inv_2
XFILLER_107_635 VGND VGND VPWR VPWR sky130_fd_sc_hd__decap_3
XFILLER_4_239 VGND VGND VPWR VPWR sky130_fd_sc_hd__decap_3
XFILLER_107_668 VGND VGND VPWR VPWR sky130_fd_sc_hd__decap_3
XFILLER_107_679 VGND VGND VPWR VPWR sky130_fd_sc_hd__decap_3
XFILLER_122_616 VGND VGND VPWR VPWR sky130_fd_sc_hd__decap_3
XFILLER_106_178 VGND VGND VPWR VPWR sky130_fd_sc_hd__decap_3
XFILLER_96_26 VGND VGND VPWR VPWR sky130_fd_sc_hd__fill_2
XFILLER_88_530 VGND VGND VPWR VPWR sky130_fd_sc_hd__fill_2
XFILLER_121_137 VGND VGND VPWR VPWR sky130_fd_sc_hd__fill_1
XFILLER_88_541 VGND VGND VPWR VPWR sky130_fd_sc_hd__decap_3
XFILLER_29_20 VGND VGND VPWR VPWR sky130_fd_sc_hd__decap_3
XFILLER_0_456 VGND VGND VPWR VPWR sky130_fd_sc_hd__fill_2
XFILLER_88_574 VGND VGND VPWR VPWR sky130_fd_sc_hd__decap_3
XFILLER_76_725 VGND VGND VPWR VPWR sky130_fd_sc_hd__decap_3
XFILLER_75_202 VGND VGND VPWR VPWR sky130_fd_sc_hd__decap_3
XFILLER_48_449 VGND VGND VPWR VPWR sky130_fd_sc_hd__decap_3
XFILLER_102_395 VGND VGND VPWR VPWR sky130_fd_sc_hd__decap_3
XFILLER_91_706 VGND VGND VPWR VPWR sky130_fd_sc_hd__decap_3
XFILLER_29_641 VGND VGND VPWR VPWR sky130_fd_sc_hd__decap_3
XFILLER_63_419 VGND VGND VPWR VPWR sky130_fd_sc_hd__decap_3
XFILLER_56_460 VGND VGND VPWR VPWR sky130_fd_sc_hd__decap_3
XFILLER_29_685 VGND VGND VPWR VPWR sky130_fd_sc_hd__decap_3
XFILLER_28_162 VGND VGND VPWR VPWR sky130_fd_sc_hd__decap_3
XFILLER_16_302 VGND VGND VPWR VPWR sky130_fd_sc_hd__decap_3
Xplace408 _3488_/B VGND VGND VPWR VPWR _4532_/S sky130_fd_sc_hd__buf_2
Xplace419 _3371_/Y VGND VGND VPWR VPWR _4471_/S sky130_fd_sc_hd__buf_2
XFILLER_44_633 VGND VGND VPWR VPWR sky130_fd_sc_hd__decap_3
XFILLER_16_324 VGND VGND VPWR VPWR sky130_fd_sc_hd__decap_3
XFILLER_83_290 VGND VGND VPWR VPWR sky130_fd_sc_hd__decap_3
XFILLER_44_666 VGND VGND VPWR VPWR sky130_fd_sc_hd__decap_3
XFILLER_31_305 VGND VGND VPWR VPWR sky130_fd_sc_hd__decap_3
XFILLER_16_379 VGND VGND VPWR VPWR sky130_fd_sc_hd__decap_3
XTAP_TAPCELL_ROW_42_812 VGND VPWR sky130_fd_sc_hd__tapvpwrvgnd_1
XFILLER_44_699 VGND VGND VPWR VPWR sky130_fd_sc_hd__fill_1
XFILLER_71_485 VGND VGND VPWR VPWR sky130_fd_sc_hd__decap_3
XFILLER_43_198 VGND VGND VPWR VPWR sky130_fd_sc_hd__decap_3
XFILLER_31_349 VGND VGND VPWR VPWR sky130_fd_sc_hd__decap_3
XFILLER_12_530 VGND VGND VPWR VPWR sky130_fd_sc_hd__fill_2
XFILLER_12_541 VGND VGND VPWR VPWR sky130_fd_sc_hd__decap_3
XFILLER_101_91 VGND VGND VPWR VPWR sky130_fd_sc_hd__decap_3
XTAP_TAPCELL_ROW_61_1055 VGND VPWR sky130_fd_sc_hd__tapvpwrvgnd_1
XTAP_TAPCELL_ROW_61_1066 VGND VPWR sky130_fd_sc_hd__tapvpwrvgnd_1
XFILLER_12_574 VGND VGND VPWR VPWR sky130_fd_sc_hd__decap_3
XFILLER_8_545 VGND VGND VPWR VPWR sky130_fd_sc_hd__decap_3
XFILLER_77_9 VGND VGND VPWR VPWR sky130_fd_sc_hd__decap_3
XFILLER_61_84 VGND VGND VPWR VPWR sky130_fd_sc_hd__decap_3
XFILLER_8_578 VGND VGND VPWR VPWR sky130_fd_sc_hd__decap_3
XFILLER_8_589 VGND VGND VPWR VPWR sky130_fd_sc_hd__decap_3
XFILLER_6_24 VGND VGND VPWR VPWR sky130_fd_sc_hd__decap_3
XANTENNA_6 _3331_/A VGND VGND VPWR VPWR sky130_fd_sc_hd__diode_2
XFILLER_6_46 VGND VGND VPWR VPWR sky130_fd_sc_hd__decap_3
XFILLER_112_104 VGND VGND VPWR VPWR sky130_fd_sc_hd__fill_1
XFILLER_113_638 VGND VGND VPWR VPWR sky130_fd_sc_hd__decap_3
XFILLER_98_338 VGND VGND VPWR VPWR sky130_fd_sc_hd__decap_3
XFILLER_106_690 VGND VGND VPWR VPWR sky130_fd_sc_hd__decap_3
XFILLER_79_552 VGND VGND VPWR VPWR sky130_fd_sc_hd__decap_3
XFILLER_67_703 VGND VGND VPWR VPWR sky130_fd_sc_hd__decap_3
XFILLER_94_511 VGND VGND VPWR VPWR sky130_fd_sc_hd__decap_3
XFILLER_121_671 VGND VGND VPWR VPWR sky130_fd_sc_hd__fill_1
XFILLER_94_522 VGND VGND VPWR VPWR sky130_fd_sc_hd__decap_3
XFILLER_121_682 VGND VGND VPWR VPWR sky130_fd_sc_hd__decap_3
XFILLER_94_533 VGND VGND VPWR VPWR sky130_fd_sc_hd__fill_2
XFILLER_120_170 VGND VGND VPWR VPWR sky130_fd_sc_hd__decap_3
XFILLER_39_449 VGND VGND VPWR VPWR sky130_fd_sc_hd__decap_3
XFILLER_94_577 VGND VGND VPWR VPWR sky130_fd_sc_hd__decap_3
XFILLER_66_268 VGND VGND VPWR VPWR sky130_fd_sc_hd__decap_3
XFILLER_82_728 VGND VGND VPWR VPWR sky130_fd_sc_hd__decap_3
XFILLER_35_600 VGND VGND VPWR VPWR sky130_fd_sc_hd__decap_3
XFILLER_47_482 VGND VGND VPWR VPWR sky130_fd_sc_hd__decap_3
XFILLER_81_249 VGND VGND VPWR VPWR sky130_fd_sc_hd__decap_3
X_6860_ _6942_/CLK _6860_/D VGND VGND VPWR VPWR _6860_/Q sky130_fd_sc_hd__dfxtp_2
XFILLER_74_290 VGND VGND VPWR VPWR sky130_fd_sc_hd__decap_3
XFILLER_62_430 VGND VGND VPWR VPWR sky130_fd_sc_hd__decap_3
XFILLER_35_644 VGND VGND VPWR VPWR sky130_fd_sc_hd__decap_3
XFILLER_34_121 VGND VGND VPWR VPWR sky130_fd_sc_hd__decap_3
XFILLER_62_463 VGND VGND VPWR VPWR sky130_fd_sc_hd__decap_3
XFILLER_35_688 VGND VGND VPWR VPWR sky130_fd_sc_hd__decap_3
X_6791_ _6965_/CLK _6791_/D VGND VGND VPWR VPWR _6791_/Q sky130_fd_sc_hd__dfxtp_2
XFILLER_50_625 VGND VGND VPWR VPWR sky130_fd_sc_hd__decap_3
XFILLER_50_669 VGND VGND VPWR VPWR sky130_fd_sc_hd__decap_3
XTAP_TAPCELL_ROW_20_528 VGND VPWR sky130_fd_sc_hd__tapvpwrvgnd_1
XFILLER_30_371 VGND VGND VPWR VPWR sky130_fd_sc_hd__decap_3
X_7412_ _7412_/A VGND VGND VPWR VPWR _7412_/X sky130_fd_sc_hd__buf_2
XPHY_EDGE_ROW_6_Right_6 VGND VGND VPWR VPWR sky130_fd_sc_hd__decap_3
X_4624_ _4624_/A _4624_/B VGND VGND VPWR VPWR _4624_/X sky130_fd_sc_hd__and2_2
XFILLER_116_410 VGND VGND VPWR VPWR sky130_fd_sc_hd__decap_3
X_7343_ clkload6/A _7343_/D _6623_/Y VGND VGND VPWR VPWR _7343_/Q sky130_fd_sc_hd__dfrtp_2
XFILLER_116_421 VGND VGND VPWR VPWR sky130_fd_sc_hd__decap_3
X_3506_ _3544_/A _3506_/B VGND VGND VPWR VPWR _3506_/Y sky130_fd_sc_hd__nand2_2
X_7274_ _7404_/CLK _7274_/D _6554_/Y VGND VGND VPWR VPWR _7274_/Q sky130_fd_sc_hd__dfrtp_2
XFILLER_89_305 VGND VGND VPWR VPWR sky130_fd_sc_hd__decap_3
XFILLER_1_209 VGND VGND VPWR VPWR sky130_fd_sc_hd__decap_3
XFILLER_104_616 VGND VGND VPWR VPWR sky130_fd_sc_hd__decap_3
X_4486_ _4486_/A0 _4552_/A _4486_/S VGND VGND VPWR VPWR _7336_/D sky130_fd_sc_hd__mux2_2
Xhold589 _6912_/Q VGND VGND VPWR VPWR _6912_/D sky130_fd_sc_hd__dlygate4sd3_1
XFILLER_103_159 VGND VGND VPWR VPWR sky130_fd_sc_hd__decap_3
X_3368_ _5129_/A _5294_/A _3310_/Y _3561_/B VGND VGND VPWR VPWR _3368_/Y sky130_fd_sc_hd__a211oi_4
XFILLER_112_660 VGND VGND VPWR VPWR sky130_fd_sc_hd__decap_3
XFILLER_85_511 VGND VGND VPWR VPWR sky130_fd_sc_hd__decap_3
XFILLER_66_18 VGND VGND VPWR VPWR sky130_fd_sc_hd__decap_3
XFILLER_58_725 VGND VGND VPWR VPWR sky130_fd_sc_hd__decap_3
Xhold1201 _7400_/Q VGND VGND VPWR VPWR _3705_/A0 sky130_fd_sc_hd__dlygate4sd3_1
XFILLER_85_522 VGND VGND VPWR VPWR sky130_fd_sc_hd__decap_3
XFILLER_66_29 VGND VGND VPWR VPWR sky130_fd_sc_hd__decap_3
Xhold1212 _7330_/Q VGND VGND VPWR VPWR _4499_/A0 sky130_fd_sc_hd__dlygate4sd3_1
XFILLER_97_382 VGND VGND VPWR VPWR sky130_fd_sc_hd__fill_1
XFILLER_112_693 VGND VGND VPWR VPWR sky130_fd_sc_hd__decap_3
X_5107_ _5156_/S _6985_/D _5105_/X _5106_/X VGND VGND VPWR VPWR _5107_/X sky130_fd_sc_hd__o22a_2
XFILLER_85_544 VGND VGND VPWR VPWR sky130_fd_sc_hd__decap_3
XFILLER_111_181 VGND VGND VPWR VPWR sky130_fd_sc_hd__decap_3
X_3299_ _3327_/B _6979_/Q _5135_/A1 VGND VGND VPWR VPWR _3328_/A sky130_fd_sc_hd__o21a_2
XFILLER_57_246 VGND VGND VPWR VPWR sky130_fd_sc_hd__decap_3
XFILLER_73_706 VGND VGND VPWR VPWR sky130_fd_sc_hd__decap_3
X_5038_ _5038_/A _5038_/B VGND VGND VPWR VPWR _5038_/X sky130_fd_sc_hd__xor2_2
XFILLER_85_588 VGND VGND VPWR VPWR sky130_fd_sc_hd__decap_3
XFILLER_122_35 VGND VGND VPWR VPWR sky130_fd_sc_hd__decap_3
XTAP_TAPCELL_ROW_28_628 VGND VPWR sky130_fd_sc_hd__tapvpwrvgnd_1
XFILLER_72_227 VGND VGND VPWR VPWR sky130_fd_sc_hd__decap_3
XFILLER_26_622 VGND VGND VPWR VPWR sky130_fd_sc_hd__decap_3
XFILLER_53_430 VGND VGND VPWR VPWR sky130_fd_sc_hd__decap_3
XFILLER_122_68 VGND VGND VPWR VPWR sky130_fd_sc_hd__decap_3
XTAP_TAPCELL_ROW_0_253 VGND VPWR sky130_fd_sc_hd__tapvpwrvgnd_1
XFILLER_65_290 VGND VGND VPWR VPWR sky130_fd_sc_hd__decap_3
XFILLER_26_666 VGND VGND VPWR VPWR sky130_fd_sc_hd__decap_3
XTAP_TAPCELL_ROW_0_264 VGND VPWR sky130_fd_sc_hd__tapvpwrvgnd_1
XFILLER_53_452 VGND VGND VPWR VPWR sky130_fd_sc_hd__decap_3
XFILLER_15_11 VGND VGND VPWR VPWR sky130_fd_sc_hd__decap_3
XFILLER_13_305 VGND VGND VPWR VPWR sky130_fd_sc_hd__decap_3
XFILLER_26_699 VGND VGND VPWR VPWR sky130_fd_sc_hd__fill_1
X_6989_ _7401_/CLK _6989_/D _6269_/Y VGND VGND VPWR VPWR _6989_/Q sky130_fd_sc_hd__dfrtp_2
XFILLER_80_271 VGND VGND VPWR VPWR sky130_fd_sc_hd__decap_3
XFILLER_13_327 VGND VGND VPWR VPWR sky130_fd_sc_hd__decap_3
XFILLER_41_647 VGND VGND VPWR VPWR sky130_fd_sc_hd__decap_3
XFILLER_15_77 VGND VGND VPWR VPWR sky130_fd_sc_hd__decap_3
XFILLER_21_371 VGND VGND VPWR VPWR sky130_fd_sc_hd__fill_1
XFILLER_21_382 VGND VGND VPWR VPWR sky130_fd_sc_hd__fill_1
XFILLER_21_393 VGND VGND VPWR VPWR sky130_fd_sc_hd__fill_1
XFILLER_5_537 VGND VGND VPWR VPWR sky130_fd_sc_hd__decap_3
XFILLER_110_3 VGND VGND VPWR VPWR sky130_fd_sc_hd__decap_3
XFILLER_119_281 VGND VGND VPWR VPWR sky130_fd_sc_hd__decap_3
XFILLER_122_435 VGND VGND VPWR VPWR sky130_fd_sc_hd__decap_3
XFILLER_1_732 VGND VGND VPWR VPWR sky130_fd_sc_hd__decap_3
XFILLER_0_231 VGND VGND VPWR VPWR sky130_fd_sc_hd__decap_3
XFILLER_122_468 VGND VGND VPWR VPWR sky130_fd_sc_hd__decap_3
XTAP_TAPCELL_ROW_8_375 VGND VPWR sky130_fd_sc_hd__tapvpwrvgnd_1
XFILLER_49_703 VGND VGND VPWR VPWR sky130_fd_sc_hd__decap_3
XFILLER_110_619 VGND VGND VPWR VPWR sky130_fd_sc_hd__decap_3
XFILLER_0_253 VGND VGND VPWR VPWR sky130_fd_sc_hd__decap_3
XFILLER_95_319 VGND VGND VPWR VPWR sky130_fd_sc_hd__decap_3
XFILLER_103_671 VGND VGND VPWR VPWR sky130_fd_sc_hd__fill_1
XFILLER_88_371 VGND VGND VPWR VPWR sky130_fd_sc_hd__decap_3
XFILLER_103_682 VGND VGND VPWR VPWR sky130_fd_sc_hd__decap_3
XFILLER_76_533 VGND VGND VPWR VPWR sky130_fd_sc_hd__fill_2
XFILLER_48_235 VGND VGND VPWR VPWR sky130_fd_sc_hd__decap_3
XFILLER_64_728 VGND VGND VPWR VPWR sky130_fd_sc_hd__decap_3
XFILLER_17_600 VGND VGND VPWR VPWR sky130_fd_sc_hd__decap_3
Xplace205 _3562_/B VGND VGND VPWR VPWR place205/X sky130_fd_sc_hd__buf_2
XFILLER_17_644 VGND VGND VPWR VPWR sky130_fd_sc_hd__decap_3
XFILLER_44_430 VGND VGND VPWR VPWR sky130_fd_sc_hd__decap_3
XFILLER_17_688 VGND VGND VPWR VPWR sky130_fd_sc_hd__decap_3
XTAP_TAPCELL_ROW_55_981 VGND VPWR sky130_fd_sc_hd__tapvpwrvgnd_1
XFILLER_71_271 VGND VGND VPWR VPWR sky130_fd_sc_hd__decap_3
XFILLER_32_625 VGND VGND VPWR VPWR sky130_fd_sc_hd__decap_3
XTAP_TAPCELL_ROW_123_1870 VGND VPWR sky130_fd_sc_hd__tapvpwrvgnd_1
XFILLER_44_496 VGND VGND VPWR VPWR sky130_fd_sc_hd__decap_3
XTAP_TAPCELL_ROW_123_1881 VGND VPWR sky130_fd_sc_hd__tapvpwrvgnd_1
XFILLER_32_669 VGND VGND VPWR VPWR sky130_fd_sc_hd__decap_3
XFILLER_31_179 VGND VGND VPWR VPWR sky130_fd_sc_hd__decap_3
XPHY_EDGE_ROW_59_Right_59 VGND VGND VPWR VPWR sky130_fd_sc_hd__decap_3
XFILLER_8_342 VGND VGND VPWR VPWR sky130_fd_sc_hd__fill_2
XFILLER_75_6 VGND VGND VPWR VPWR sky130_fd_sc_hd__decap_3
XFILLER_118_719 VGND VGND VPWR VPWR sky130_fd_sc_hd__decap_3
XFILLER_99_603 VGND VGND VPWR VPWR sky130_fd_sc_hd__decap_3
X_4340_ _7223_/Q _4349_/B1 _4338_/X _4339_/X VGND VGND VPWR VPWR _4340_/X sky130_fd_sc_hd__a211o_2
XTAP_TAPCELL_ROW_74_1224 VGND VPWR sky130_fd_sc_hd__tapvpwrvgnd_1
XFILLER_113_402 VGND VGND VPWR VPWR sky130_fd_sc_hd__decap_3
XTAP_TAPCELL_ROW_74_1235 VGND VPWR sky130_fd_sc_hd__tapvpwrvgnd_1
XFILLER_99_647 VGND VGND VPWR VPWR sky130_fd_sc_hd__decap_3
XFILLER_98_124 VGND VGND VPWR VPWR sky130_fd_sc_hd__decap_3
XFILLER_4_581 VGND VGND VPWR VPWR sky130_fd_sc_hd__decap_3
XFILLER_113_424 VGND VGND VPWR VPWR sky130_fd_sc_hd__decap_3
X_4271_ _4271_/A _4271_/B _4271_/C _4270_/Y VGND VGND VPWR VPWR _4271_/X sky130_fd_sc_hd__or4b_2
XFILLER_4_592 VGND VGND VPWR VPWR sky130_fd_sc_hd__decap_3
XFILLER_98_157 VGND VGND VPWR VPWR sky130_fd_sc_hd__decap_3
XFILLER_98_179 VGND VGND VPWR VPWR sky130_fd_sc_hd__decap_3
XFILLER_67_500 VGND VGND VPWR VPWR sky130_fd_sc_hd__decap_3
XPHY_EDGE_ROW_68_Right_68 VGND VGND VPWR VPWR sky130_fd_sc_hd__decap_3
XFILLER_67_511 VGND VGND VPWR VPWR sky130_fd_sc_hd__decap_3
XFILLER_79_393 VGND VGND VPWR VPWR sky130_fd_sc_hd__decap_3
XFILLER_39_246 VGND VGND VPWR VPWR sky130_fd_sc_hd__decap_3
XFILLER_55_706 VGND VGND VPWR VPWR sky130_fd_sc_hd__decap_3
XFILLER_27_408 VGND VGND VPWR VPWR sky130_fd_sc_hd__decap_3
XFILLER_54_205 VGND VGND VPWR VPWR sky130_fd_sc_hd__decap_3
XFILLER_82_536 VGND VGND VPWR VPWR sky130_fd_sc_hd__decap_3
X_6912_ _6965_/CLK _6912_/D VGND VGND VPWR VPWR _6912_/Q sky130_fd_sc_hd__dfxtp_2
XFILLER_54_249 VGND VGND VPWR VPWR sky130_fd_sc_hd__decap_3
XTAP_TAPCELL_ROW_85_1375 VGND VPWR sky130_fd_sc_hd__tapvpwrvgnd_1
X_6843_ _6978_/CLK _6843_/D VGND VGND VPWR VPWR _6843_/Q sky130_fd_sc_hd__dfxtp_2
XFILLER_50_411 VGND VGND VPWR VPWR sky130_fd_sc_hd__decap_3
XFILLER_22_113 VGND VGND VPWR VPWR sky130_fd_sc_hd__decap_3
XFILLER_23_647 VGND VGND VPWR VPWR sky130_fd_sc_hd__decap_3
XFILLER_50_433 VGND VGND VPWR VPWR sky130_fd_sc_hd__decap_3
X_6774_ clkload8/A _6774_/D VGND VGND VPWR VPWR _6774_/Q sky130_fd_sc_hd__dfxtp_2
XPHY_EDGE_ROW_77_Right_77 VGND VGND VPWR VPWR sky130_fd_sc_hd__decap_3
XPHY_EDGE_ROW_99_Left_223 VGND VGND VPWR VPWR sky130_fd_sc_hd__decap_3
XFILLER_50_477 VGND VGND VPWR VPWR sky130_fd_sc_hd__fill_1
X_5725_ _7368_/Q hold917/X _5735_/S VGND VGND VPWR VPWR _6712_/D sky130_fd_sc_hd__mux2_2
XTAP_TAPCELL_ROW_33_697 VGND VPWR sky130_fd_sc_hd__tapvpwrvgnd_1
XFILLER_31_691 VGND VGND VPWR VPWR sky130_fd_sc_hd__decap_3
X_5656_ _5656_/A _5656_/B _5656_/C VGND VGND VPWR VPWR _5665_/C sky130_fd_sc_hd__nor3_2
XFILLER_30_190 VGND VGND VPWR VPWR sky130_fd_sc_hd__decap_3
XFILLER_108_229 VGND VGND VPWR VPWR sky130_fd_sc_hd__fill_2
X_5587_ _5587_/A _5587_/B VGND VGND VPWR VPWR _7034_/D sky130_fd_sc_hd__and2_2
X_7326_ _7359_/CLK _7326_/D _6606_/Y VGND VGND VPWR VPWR _7326_/Q sky130_fd_sc_hd__dfrtp_2
XFILLER_2_507 VGND VGND VPWR VPWR sky130_fd_sc_hd__decap_3
XFILLER_117_24 VGND VGND VPWR VPWR sky130_fd_sc_hd__decap_3
XFILLER_89_113 VGND VGND VPWR VPWR sky130_fd_sc_hd__decap_3
XFILLER_104_424 VGND VGND VPWR VPWR sky130_fd_sc_hd__decap_3
XFILLER_117_57 VGND VGND VPWR VPWR sky130_fd_sc_hd__decap_3
X_7257_ _7325_/CLK _7257_/D _6537_/Y VGND VGND VPWR VPWR _7257_/Q sky130_fd_sc_hd__dfrtp_2
X_4469_ _7009_/Q _4467_/A _3332_/B _4468_/X VGND VGND VPWR VPWR _4469_/X sky130_fd_sc_hd__a31o_2
XPHY_EDGE_ROW_86_Right_86 VGND VGND VPWR VPWR sky130_fd_sc_hd__decap_3
XFILLER_104_457 VGND VGND VPWR VPWR sky130_fd_sc_hd__fill_2
XFILLER_77_308 VGND VGND VPWR VPWR sky130_fd_sc_hd__decap_3
XFILLER_104_468 VGND VGND VPWR VPWR sky130_fd_sc_hd__decap_3
X_7188_ clkload6/A _7188_/D _6468_/Y VGND VGND VPWR VPWR _7188_/Q sky130_fd_sc_hd__dfrtp_2
XTAP_TAPCELL_ROW_5_334 VGND VPWR sky130_fd_sc_hd__tapvpwrvgnd_1
XFILLER_58_533 VGND VGND VPWR VPWR sky130_fd_sc_hd__fill_2
Xhold1020 _7268_/Q VGND VGND VPWR VPWR _4901_/A0 sky130_fd_sc_hd__dlygate4sd3_1
Xhold1031 _6716_/Q VGND VGND VPWR VPWR _5733_/A1 sky130_fd_sc_hd__dlygate4sd3_1
Xhold1042 _7277_/Q VGND VGND VPWR VPWR _4735_/A0 sky130_fd_sc_hd__dlygate4sd3_1
XFILLER_100_663 VGND VGND VPWR VPWR sky130_fd_sc_hd__decap_3
Xhold1053 _7227_/Q VGND VGND VPWR VPWR _5203_/A sky130_fd_sc_hd__dlygate4sd3_1
XFILLER_85_363 VGND VGND VPWR VPWR sky130_fd_sc_hd__fill_2
XFILLER_73_503 VGND VGND VPWR VPWR sky130_fd_sc_hd__fill_1
XFILLER_46_728 VGND VGND VPWR VPWR sky130_fd_sc_hd__decap_3
XFILLER_85_374 VGND VGND VPWR VPWR sky130_fd_sc_hd__decap_3
XFILLER_45_205 VGND VGND VPWR VPWR sky130_fd_sc_hd__decap_3
Xhold1064 _7249_/Q VGND VGND VPWR VPWR _5142_/A0 sky130_fd_sc_hd__dlygate4sd3_1
XFILLER_58_599 VGND VGND VPWR VPWR sky130_fd_sc_hd__decap_3
Xhold1075 _7217_/Q VGND VGND VPWR VPWR _5223_/A sky130_fd_sc_hd__dlygate4sd3_1
XFILLER_100_696 VGND VGND VPWR VPWR sky130_fd_sc_hd__decap_3
Xhold1086 _7327_/Q VGND VGND VPWR VPWR _4505_/A0 sky130_fd_sc_hd__dlygate4sd3_1
Xhold1097 _7137_/Q VGND VGND VPWR VPWR _5392_/A0 sky130_fd_sc_hd__dlygate4sd3_1
XFILLER_61_709 VGND VGND VPWR VPWR sky130_fd_sc_hd__decap_3
XFILLER_26_474 VGND VGND VPWR VPWR sky130_fd_sc_hd__fill_2
XFILLER_14_625 VGND VGND VPWR VPWR sky130_fd_sc_hd__decap_3
XPHY_EDGE_ROW_95_Right_95 VGND VGND VPWR VPWR sky130_fd_sc_hd__decap_3
XFILLER_81_591 VGND VGND VPWR VPWR sky130_fd_sc_hd__decap_3
XFILLER_53_293 VGND VGND VPWR VPWR sky130_fd_sc_hd__decap_3
XTAP_TAPCELL_ROW_52_940 VGND VPWR sky130_fd_sc_hd__tapvpwrvgnd_1
XFILLER_14_669 VGND VGND VPWR VPWR sky130_fd_sc_hd__decap_3
XFILLER_42_20 VGND VGND VPWR VPWR sky130_fd_sc_hd__decap_3
XFILLER_41_477 VGND VGND VPWR VPWR sky130_fd_sc_hd__decap_3
XFILLER_107_240 VGND VGND VPWR VPWR sky130_fd_sc_hd__decap_3
XFILLER_107_284 VGND VGND VPWR VPWR sky130_fd_sc_hd__decap_3
XFILLER_107_295 VGND VGND VPWR VPWR sky130_fd_sc_hd__decap_3
XFILLER_3_14 VGND VGND VPWR VPWR sky130_fd_sc_hd__decap_3
XFILLER_96_628 VGND VGND VPWR VPWR sky130_fd_sc_hd__decap_3
XFILLER_95_105 VGND VGND VPWR VPWR sky130_fd_sc_hd__fill_2
XFILLER_49_500 VGND VGND VPWR VPWR sky130_fd_sc_hd__decap_3
XFILLER_95_116 VGND VGND VPWR VPWR sky130_fd_sc_hd__fill_1
XFILLER_49_511 VGND VGND VPWR VPWR sky130_fd_sc_hd__decap_3
XFILLER_1_573 VGND VGND VPWR VPWR sky130_fd_sc_hd__decap_3
XFILLER_89_691 VGND VGND VPWR VPWR sky130_fd_sc_hd__decap_3
XFILLER_95_138 VGND VGND VPWR VPWR sky130_fd_sc_hd__decap_3
XFILLER_37_706 VGND VGND VPWR VPWR sky130_fd_sc_hd__decap_3
XFILLER_76_363 VGND VGND VPWR VPWR sky130_fd_sc_hd__fill_1
XFILLER_64_514 VGND VGND VPWR VPWR sky130_fd_sc_hd__decap_3
XFILLER_36_249 VGND VGND VPWR VPWR sky130_fd_sc_hd__decap_3
XFILLER_29_290 VGND VGND VPWR VPWR sky130_fd_sc_hd__decap_3
XFILLER_83_60 VGND VGND VPWR VPWR sky130_fd_sc_hd__fill_1
XFILLER_51_208 VGND VGND VPWR VPWR sky130_fd_sc_hd__decap_3
XFILLER_60_731 VGND VGND VPWR VPWR sky130_fd_sc_hd__decap_3
XFILLER_44_293 VGND VGND VPWR VPWR sky130_fd_sc_hd__decap_3
X_3840_ _6835_/Q _3840_/A2 _3850_/B1 _6840_/Q VGND VGND VPWR VPWR _3840_/X sky130_fd_sc_hd__a22o_2
XFILLER_20_628 VGND VGND VPWR VPWR sky130_fd_sc_hd__decap_3
X_3771_ _6910_/Q _3888_/A2 _3889_/A2 _6862_/Q VGND VGND VPWR VPWR _3771_/X sky130_fd_sc_hd__a22o_2
XFILLER_13_691 VGND VGND VPWR VPWR sky130_fd_sc_hd__decap_3
XFILLER_9_662 VGND VGND VPWR VPWR sky130_fd_sc_hd__decap_3
XTAP_TAPCELL_ROW_30_656 VGND VPWR sky130_fd_sc_hd__tapvpwrvgnd_1
XFILLER_9_673 VGND VGND VPWR VPWR sky130_fd_sc_hd__decap_3
X_6490_ _6674_/A VGND VGND VPWR VPWR _6490_/Y sky130_fd_sc_hd__inv_2
XFILLER_73_3 VGND VGND VPWR VPWR sky130_fd_sc_hd__decap_3
XFILLER_118_516 VGND VGND VPWR VPWR sky130_fd_sc_hd__decap_3
XFILLER_8_172 VGND VGND VPWR VPWR sky130_fd_sc_hd__decap_3
XTAP_TAPCELL_ROW_10_391 VGND VPWR sky130_fd_sc_hd__tapvpwrvgnd_1
XFILLER_114_722 VGND VGND VPWR VPWR sky130_fd_sc_hd__decap_3
X_7111_ _7372_/CLK _7111_/D _6391_/Y VGND VGND VPWR VPWR _7111_/Q sky130_fd_sc_hd__dfrtp_2
X_4323_ _7226_/Q _4353_/A2 _3975_/S _7194_/Q VGND VGND VPWR VPWR _4323_/X sky130_fd_sc_hd__a22o_2
XFILLER_99_444 VGND VGND VPWR VPWR sky130_fd_sc_hd__decap_3
Xoutput469 _5662_/C VGND VGND VPWR VPWR alu_result_out[17] sky130_fd_sc_hd__clkdlybuf4s25_1
XFILLER_87_606 VGND VGND VPWR VPWR sky130_fd_sc_hd__decap_3
XFILLER_87_617 VGND VGND VPWR VPWR sky130_fd_sc_hd__decap_3
X_7042_ _7362_/CLK _7042_/D _6322_/Y VGND VGND VPWR VPWR _7042_/Q sky130_fd_sc_hd__dfrtp_2
XFILLER_86_105 VGND VGND VPWR VPWR sky130_fd_sc_hd__decap_3
XFILLER_59_319 VGND VGND VPWR VPWR sky130_fd_sc_hd__decap_3
X_4254_ _7229_/Q _4414_/A2 _4244_/B _7042_/Q _4253_/X VGND VGND VPWR VPWR _4254_/X
+ sky130_fd_sc_hd__a221o_2
XFILLER_101_416 VGND VGND VPWR VPWR sky130_fd_sc_hd__decap_3
XFILLER_113_287 VGND VGND VPWR VPWR sky130_fd_sc_hd__decap_3
XFILLER_86_138 VGND VGND VPWR VPWR sky130_fd_sc_hd__fill_2
XFILLER_101_449 VGND VGND VPWR VPWR sky130_fd_sc_hd__decap_3
X_4185_ _4289_/A _5708_/S _4185_/C VGND VGND VPWR VPWR _4636_/B sky130_fd_sc_hd__and3_2
XFILLER_95_650 VGND VGND VPWR VPWR sky130_fd_sc_hd__decap_3
XTAP_TAPCELL_ROW_87_1404 VGND VPWR sky130_fd_sc_hd__tapvpwrvgnd_1
XFILLER_55_514 VGND VGND VPWR VPWR sky130_fd_sc_hd__fill_1
XFILLER_28_728 VGND VGND VPWR VPWR sky130_fd_sc_hd__decap_3
XFILLER_95_694 VGND VGND VPWR VPWR sky130_fd_sc_hd__decap_3
XFILLER_94_171 VGND VGND VPWR VPWR sky130_fd_sc_hd__decap_3
XTAP_TAPCELL_ROW_38_756 VGND VPWR sky130_fd_sc_hd__tapvpwrvgnd_1
XFILLER_43_709 VGND VGND VPWR VPWR sky130_fd_sc_hd__decap_3
XTAP_TAPCELL_ROW_38_767 VGND VPWR sky130_fd_sc_hd__tapvpwrvgnd_1
XFILLER_70_528 VGND VGND VPWR VPWR sky130_fd_sc_hd__decap_3
XFILLER_82_388 VGND VGND VPWR VPWR sky130_fd_sc_hd__fill_2
XFILLER_35_271 VGND VGND VPWR VPWR sky130_fd_sc_hd__decap_3
XFILLER_35_293 VGND VGND VPWR VPWR sky130_fd_sc_hd__decap_3
X_6826_ clkload8/A _6826_/D VGND VGND VPWR VPWR _6826_/Q sky130_fd_sc_hd__dfxtp_2
XFILLER_23_444 VGND VGND VPWR VPWR sky130_fd_sc_hd__decap_3
XFILLER_11_606 VGND VGND VPWR VPWR sky130_fd_sc_hd__decap_3
XFILLER_11_617 VGND VGND VPWR VPWR sky130_fd_sc_hd__decap_3
XFILLER_50_274 VGND VGND VPWR VPWR sky130_fd_sc_hd__decap_3
X_6757_ clkload9/A _6757_/D VGND VGND VPWR VPWR _6757_/Q sky130_fd_sc_hd__dfxtp_2
XFILLER_23_499 VGND VGND VPWR VPWR sky130_fd_sc_hd__decap_3
X_5708_ _7360_/Q _5708_/A1 _5708_/S VGND VGND VPWR VPWR _6704_/D sky130_fd_sc_hd__mux2_2
XFILLER_109_505 VGND VGND VPWR VPWR sky130_fd_sc_hd__fill_2
XTAP_TAPCELL_ROW_98_1544 VGND VPWR sky130_fd_sc_hd__tapvpwrvgnd_1
X_6688_ _7215_/CLK _6688_/D VGND VGND VPWR VPWR _6688_/Q sky130_fd_sc_hd__dfxtp_2
XFILLER_109_549 VGND VGND VPWR VPWR sky130_fd_sc_hd__decap_3
XFILLER_12_78 VGND VGND VPWR VPWR sky130_fd_sc_hd__decap_3
XFILLER_105_700 VGND VGND VPWR VPWR sky130_fd_sc_hd__decap_3
XFILLER_2_315 VGND VGND VPWR VPWR sky130_fd_sc_hd__decap_3
XFILLER_117_582 VGND VGND VPWR VPWR sky130_fd_sc_hd__decap_3
X_7309_ _7368_/CLK _7309_/D _6589_/Y VGND VGND VPWR VPWR _7309_/Q sky130_fd_sc_hd__dfrtp_2
XFILLER_104_243 VGND VGND VPWR VPWR sky130_fd_sc_hd__decap_3
XFILLER_78_628 VGND VGND VPWR VPWR sky130_fd_sc_hd__decap_3
XFILLER_77_105 VGND VGND VPWR VPWR sky130_fd_sc_hd__decap_3
XFILLER_120_725 VGND VGND VPWR VPWR sky130_fd_sc_hd__decap_3
XFILLER_77_116 VGND VGND VPWR VPWR sky130_fd_sc_hd__decap_3
XFILLER_77_138 VGND VGND VPWR VPWR sky130_fd_sc_hd__decap_3
XFILLER_93_609 VGND VGND VPWR VPWR sky130_fd_sc_hd__decap_3
XFILLER_19_706 VGND VGND VPWR VPWR sky130_fd_sc_hd__decap_3
XFILLER_58_352 VGND VGND VPWR VPWR sky130_fd_sc_hd__decap_3
XFILLER_86_672 VGND VGND VPWR VPWR sky130_fd_sc_hd__decap_3
XFILLER_58_374 VGND VGND VPWR VPWR sky130_fd_sc_hd__decap_3
XFILLER_18_205 VGND VGND VPWR VPWR sky130_fd_sc_hd__decap_3
XFILLER_18_238 VGND VGND VPWR VPWR sky130_fd_sc_hd__fill_2
XFILLER_73_333 VGND VGND VPWR VPWR sky130_fd_sc_hd__decap_3
XFILLER_61_517 VGND VGND VPWR VPWR sky130_fd_sc_hd__decap_3
XTAP_TAPCELL_ROW_107_1662 VGND VPWR sky130_fd_sc_hd__tapvpwrvgnd_1
XFILLER_42_731 VGND VGND VPWR VPWR sky130_fd_sc_hd__decap_3
XFILLER_41_263 VGND VGND VPWR VPWR sky130_fd_sc_hd__decap_3
XFILLER_14_477 VGND VGND VPWR VPWR sky130_fd_sc_hd__fill_2
XFILLER_6_610 VGND VGND VPWR VPWR sky130_fd_sc_hd__decap_3
XFILLER_10_672 VGND VGND VPWR VPWR sky130_fd_sc_hd__decap_3
XFILLER_6_643 VGND VGND VPWR VPWR sky130_fd_sc_hd__fill_1
XTAP_TAPCELL_ROW_58_1016 VGND VPWR sky130_fd_sc_hd__tapvpwrvgnd_1
XFILLER_6_654 VGND VGND VPWR VPWR sky130_fd_sc_hd__decap_3
XTAP_TAPCELL_ROW_58_1027 VGND VPWR sky130_fd_sc_hd__tapvpwrvgnd_1
XFILLER_115_508 VGND VGND VPWR VPWR sky130_fd_sc_hd__decap_3
XFILLER_108_560 VGND VGND VPWR VPWR sky130_fd_sc_hd__decap_3
XFILLER_6_687 VGND VGND VPWR VPWR sky130_fd_sc_hd__decap_3
XFILLER_5_164 VGND VGND VPWR VPWR sky130_fd_sc_hd__decap_3
XFILLER_69_606 VGND VGND VPWR VPWR sky130_fd_sc_hd__decap_3
XFILLER_69_617 VGND VGND VPWR VPWR sky130_fd_sc_hd__decap_3
XFILLER_111_703 VGND VGND VPWR VPWR sky130_fd_sc_hd__decap_3
XFILLER_96_447 VGND VGND VPWR VPWR sky130_fd_sc_hd__decap_3
XFILLER_68_138 VGND VGND VPWR VPWR sky130_fd_sc_hd__fill_2
XFILLER_77_650 VGND VGND VPWR VPWR sky130_fd_sc_hd__decap_3
XFILLER_37_503 VGND VGND VPWR VPWR sky130_fd_sc_hd__fill_1
XFILLER_83_119 VGND VGND VPWR VPWR sky130_fd_sc_hd__decap_3
XFILLER_37_525 VGND VGND VPWR VPWR sky130_fd_sc_hd__decap_3
XFILLER_77_694 VGND VGND VPWR VPWR sky130_fd_sc_hd__decap_3
XFILLER_92_631 VGND VGND VPWR VPWR sky130_fd_sc_hd__decap_3
XFILLER_94_70 VGND VGND VPWR VPWR sky130_fd_sc_hd__decap_3
XFILLER_37_558 VGND VGND VPWR VPWR sky130_fd_sc_hd__fill_2
XFILLER_37_569 VGND VGND VPWR VPWR sky130_fd_sc_hd__fill_1
XFILLER_25_709 VGND VGND VPWR VPWR sky130_fd_sc_hd__decap_3
XTAP_TAPCELL_ROW_69_1167 VGND VPWR sky130_fd_sc_hd__tapvpwrvgnd_1
XFILLER_92_675 VGND VGND VPWR VPWR sky130_fd_sc_hd__decap_3
XFILLER_64_388 VGND VGND VPWR VPWR sky130_fd_sc_hd__decap_3
XFILLER_52_528 VGND VGND VPWR VPWR sky130_fd_sc_hd__decap_3
XTAP_TAPCELL_ROW_35_726 VGND VPWR sky130_fd_sc_hd__tapvpwrvgnd_1
X_4941_ _4811_/C _4936_/Y _4940_/Y VGND VGND VPWR VPWR _5657_/C sky130_fd_sc_hd__a21o_2
XFILLER_52_539 VGND VGND VPWR VPWR sky130_fd_sc_hd__decap_3
XTAP_TAPCELL_ROW_82_1334 VGND VPWR sky130_fd_sc_hd__tapvpwrvgnd_1
X_4872_ _4872_/A _4872_/B VGND VGND VPWR VPWR _4872_/X sky130_fd_sc_hd__and2_2
X_6611_ _6613_/A VGND VGND VPWR VPWR _6611_/Y sky130_fd_sc_hd__inv_2
XTAP_TAPCELL_ROW_15_461 VGND VPWR sky130_fd_sc_hd__tapvpwrvgnd_1
X_3823_ _6947_/Q _3884_/B1 _3912_/B1 _6959_/Q VGND VGND VPWR VPWR _3823_/X sky130_fd_sc_hd__a22o_2
XFILLER_32_285 VGND VGND VPWR VPWR sky130_fd_sc_hd__decap_3
X_6542_ _6542_/A VGND VGND VPWR VPWR _6542_/Y sky130_fd_sc_hd__inv_2
X_3754_ _3754_/A1 _4832_/A _3753_/X VGND VGND VPWR VPWR _7397_/D sky130_fd_sc_hd__o21a_2
XFILLER_118_335 VGND VGND VPWR VPWR sky130_fd_sc_hd__decap_3
X_6473_ _6644_/A VGND VGND VPWR VPWR _6473_/Y sky130_fd_sc_hd__inv_2
XTAP_TAPCELL_ROW_93_1474 VGND VPWR sky130_fd_sc_hd__tapvpwrvgnd_1
XFILLER_114_563 VGND VGND VPWR VPWR sky130_fd_sc_hd__decap_3
X_4306_ _7288_/Q _5080_/S _4335_/B1 _7096_/Q VGND VGND VPWR VPWR _4311_/A sky130_fd_sc_hd__a22o_2
XFILLER_99_274 VGND VGND VPWR VPWR sky130_fd_sc_hd__decap_3
XFILLER_102_725 VGND VGND VPWR VPWR sky130_fd_sc_hd__decap_3
XFILLER_101_202 VGND VGND VPWR VPWR sky130_fd_sc_hd__decap_3
X_5286_ _5286_/A0 _5139_/X _5292_/S VGND VGND VPWR VPWR _7186_/D sky130_fd_sc_hd__mux2_2
XFILLER_87_425 VGND VGND VPWR VPWR sky130_fd_sc_hd__decap_3
X_7025_ _7374_/CLK _7025_/D _6305_/Y VGND VGND VPWR VPWR _7025_/Q sky130_fd_sc_hd__dfrtp_2
X_4237_ _7259_/Q _4601_/S _4236_/X VGND VGND VPWR VPWR _4237_/X sky130_fd_sc_hd__a21o_2
XFILLER_75_609 VGND VGND VPWR VPWR sky130_fd_sc_hd__decap_3
XFILLER_74_108 VGND VGND VPWR VPWR sky130_fd_sc_hd__fill_1
XFILLER_68_672 VGND VGND VPWR VPWR sky130_fd_sc_hd__decap_3
XFILLER_114_47 VGND VGND VPWR VPWR sky130_fd_sc_hd__decap_3
XFILLER_101_279 VGND VGND VPWR VPWR sky130_fd_sc_hd__fill_1
XFILLER_67_160 VGND VGND VPWR VPWR sky130_fd_sc_hd__decap_3
X_4168_ _7046_/Q _4429_/A2 _4108_/B _7361_/Q _4167_/X VGND VGND VPWR VPWR _4168_/X
+ sky130_fd_sc_hd__a221o_2
XFILLER_83_620 VGND VGND VPWR VPWR sky130_fd_sc_hd__decap_3
XFILLER_74_18 VGND VGND VPWR VPWR sky130_fd_sc_hd__decap_3
XFILLER_55_322 VGND VGND VPWR VPWR sky130_fd_sc_hd__decap_3
XFILLER_28_536 VGND VGND VPWR VPWR sky130_fd_sc_hd__decap_3
XFILLER_74_29 VGND VGND VPWR VPWR sky130_fd_sc_hd__decap_3
XFILLER_55_333 VGND VGND VPWR VPWR sky130_fd_sc_hd__decap_3
XFILLER_28_547 VGND VGND VPWR VPWR sky130_fd_sc_hd__decap_3
XFILLER_83_653 VGND VGND VPWR VPWR sky130_fd_sc_hd__decap_3
XFILLER_82_141 VGND VGND VPWR VPWR sky130_fd_sc_hd__decap_3
X_4099_ _7301_/Q _4497_/S _4459_/C1 _7173_/Q _4098_/X VGND VGND VPWR VPWR _4099_/X
+ sky130_fd_sc_hd__a221o_2
XFILLER_82_163 VGND VGND VPWR VPWR sky130_fd_sc_hd__decap_3
XFILLER_83_697 VGND VGND VPWR VPWR sky130_fd_sc_hd__decap_3
XFILLER_82_185 VGND VGND VPWR VPWR sky130_fd_sc_hd__decap_3
XFILLER_55_399 VGND VGND VPWR VPWR sky130_fd_sc_hd__decap_3
XFILLER_70_336 VGND VGND VPWR VPWR sky130_fd_sc_hd__fill_2
XFILLER_24_731 VGND VGND VPWR VPWR sky130_fd_sc_hd__decap_3
XFILLER_23_241 VGND VGND VPWR VPWR sky130_fd_sc_hd__fill_1
XFILLER_51_561 VGND VGND VPWR VPWR sky130_fd_sc_hd__decap_3
X_6809_ clkload9/A _6809_/D VGND VGND VPWR VPWR _6809_/Q sky130_fd_sc_hd__dfxtp_2
XFILLER_11_414 VGND VGND VPWR VPWR sky130_fd_sc_hd__decap_3
XFILLER_11_447 VGND VGND VPWR VPWR sky130_fd_sc_hd__fill_1
XTAP_TAPCELL_ROW_102_1592 VGND VPWR sky130_fd_sc_hd__tapvpwrvgnd_1
XFILLER_7_418 VGND VGND VPWR VPWR sky130_fd_sc_hd__decap_3
XFILLER_11_469 VGND VGND VPWR VPWR sky130_fd_sc_hd__decap_3
XFILLER_109_324 VGND VGND VPWR VPWR sky130_fd_sc_hd__decap_3
XFILLER_99_26 VGND VGND VPWR VPWR sky130_fd_sc_hd__decap_3
XFILLER_109_346 VGND VGND VPWR VPWR sky130_fd_sc_hd__decap_3
XFILLER_99_48 VGND VGND VPWR VPWR sky130_fd_sc_hd__decap_3
XFILLER_109_368 VGND VGND VPWR VPWR sky130_fd_sc_hd__decap_3
XFILLER_3_635 VGND VGND VPWR VPWR sky130_fd_sc_hd__decap_3
XFILLER_117_390 VGND VGND VPWR VPWR sky130_fd_sc_hd__fill_2
XFILLER_3_668 VGND VGND VPWR VPWR sky130_fd_sc_hd__decap_3
XFILLER_105_552 VGND VGND VPWR VPWR sky130_fd_sc_hd__decap_3
XFILLER_3_679 VGND VGND VPWR VPWR sky130_fd_sc_hd__decap_3
XFILLER_105_585 VGND VGND VPWR VPWR sky130_fd_sc_hd__decap_3
XFILLER_2_189 VGND VGND VPWR VPWR sky130_fd_sc_hd__decap_3
XFILLER_120_522 VGND VGND VPWR VPWR sky130_fd_sc_hd__decap_3
XFILLER_120_533 VGND VGND VPWR VPWR sky130_fd_sc_hd__decap_3
XFILLER_66_609 VGND VGND VPWR VPWR sky130_fd_sc_hd__decap_3
XFILLER_78_469 VGND VGND VPWR VPWR sky130_fd_sc_hd__decap_3
XFILLER_59_650 VGND VGND VPWR VPWR sky130_fd_sc_hd__decap_3
XFILLER_120_566 VGND VGND VPWR VPWR sky130_fd_sc_hd__decap_3
XFILLER_19_503 VGND VGND VPWR VPWR sky130_fd_sc_hd__fill_1
XFILLER_19_514 VGND VGND VPWR VPWR sky130_fd_sc_hd__fill_1
XFILLER_59_694 VGND VGND VPWR VPWR sky130_fd_sc_hd__decap_3
XPHY_EDGE_ROW_45_Left_169 VGND VGND VPWR VPWR sky130_fd_sc_hd__decap_3
XFILLER_86_491 VGND VGND VPWR VPWR sky130_fd_sc_hd__decap_3
XFILLER_74_631 VGND VGND VPWR VPWR sky130_fd_sc_hd__decap_3
XFILLER_58_182 VGND VGND VPWR VPWR sky130_fd_sc_hd__decap_3
XFILLER_46_333 VGND VGND VPWR VPWR sky130_fd_sc_hd__decap_3
XFILLER_74_675 VGND VGND VPWR VPWR sky130_fd_sc_hd__decap_3
XFILLER_104_80 VGND VGND VPWR VPWR sky130_fd_sc_hd__decap_3
XFILLER_34_517 VGND VGND VPWR VPWR sky130_fd_sc_hd__decap_3
XFILLER_34_539 VGND VGND VPWR VPWR sky130_fd_sc_hd__fill_2
XFILLER_64_73 VGND VGND VPWR VPWR sky130_fd_sc_hd__decap_3
XFILLER_61_369 VGND VGND VPWR VPWR sky130_fd_sc_hd__fill_2
XFILLER_30_701 VGND VGND VPWR VPWR sky130_fd_sc_hd__decap_3
XFILLER_30_734 VGND VGND VPWR VPWR sky130_fd_sc_hd__fill_1
XFILLER_9_57 VGND VGND VPWR VPWR sky130_fd_sc_hd__fill_2
XTAP_TAPCELL_ROW_64_1097 VGND VPWR sky130_fd_sc_hd__tapvpwrvgnd_1
XTAP_TAPCELL_ROW_12_420 VGND VPWR sky130_fd_sc_hd__tapvpwrvgnd_1
XPHY_EDGE_ROW_54_Left_178 VGND VGND VPWR VPWR sky130_fd_sc_hd__decap_3
XFILLER_80_94 VGND VGND VPWR VPWR sky130_fd_sc_hd__decap_3
XTAP_TAPCELL_ROW_40_784 VGND VPWR sky130_fd_sc_hd__tapvpwrvgnd_1
Xhold908 _6688_/Q VGND VGND VPWR VPWR hold908/X sky130_fd_sc_hd__dlygate4sd3_1
XFILLER_115_305 VGND VGND VPWR VPWR sky130_fd_sc_hd__fill_1
Xhold919 _6693_/Q VGND VGND VPWR VPWR hold919/X sky130_fd_sc_hd__dlygate4sd3_1
X_3470_ _3468_/X _3424_/S _4537_/C _4537_/B VGND VGND VPWR VPWR _3545_/B sky130_fd_sc_hd__o2bb2a_2
XFILLER_97_712 VGND VGND VPWR VPWR sky130_fd_sc_hd__decap_3
X_5140_ _5140_/A0 _5139_/X _5140_/S VGND VGND VPWR VPWR _7250_/D sky130_fd_sc_hd__mux2_2
XFILLER_123_371 VGND VGND VPWR VPWR sky130_fd_sc_hd__decap_3
XFILLER_96_211 VGND VGND VPWR VPWR sky130_fd_sc_hd__decap_3
XFILLER_69_436 VGND VGND VPWR VPWR sky130_fd_sc_hd__decap_3
XFILLER_111_522 VGND VGND VPWR VPWR sky130_fd_sc_hd__decap_3
XFILLER_2_690 VGND VGND VPWR VPWR sky130_fd_sc_hd__decap_3
XFILLER_123_393 VGND VGND VPWR VPWR sky130_fd_sc_hd__decap_3
XFILLER_69_458 VGND VGND VPWR VPWR sky130_fd_sc_hd__decap_3
X_5071_ _5071_/A _5071_/B VGND VGND VPWR VPWR _5072_/C sky130_fd_sc_hd__nand2_2
XFILLER_111_555 VGND VGND VPWR VPWR sky130_fd_sc_hd__decap_3
XFILLER_84_406 VGND VGND VPWR VPWR sky130_fd_sc_hd__decap_3
XPHY_EDGE_ROW_63_Left_187 VGND VGND VPWR VPWR sky130_fd_sc_hd__decap_3
XFILLER_56_108 VGND VGND VPWR VPWR sky130_fd_sc_hd__decap_3
XFILLER_111_588 VGND VGND VPWR VPWR sky130_fd_sc_hd__decap_3
XFILLER_65_620 VGND VGND VPWR VPWR sky130_fd_sc_hd__decap_3
XFILLER_77_491 VGND VGND VPWR VPWR sky130_fd_sc_hd__decap_3
XFILLER_37_322 VGND VGND VPWR VPWR sky130_fd_sc_hd__decap_3
XFILLER_65_653 VGND VGND VPWR VPWR sky130_fd_sc_hd__decap_3
XFILLER_37_355 VGND VGND VPWR VPWR sky130_fd_sc_hd__decap_3
XFILLER_92_450 VGND VGND VPWR VPWR sky130_fd_sc_hd__decap_3
XFILLER_80_601 VGND VGND VPWR VPWR sky130_fd_sc_hd__decap_3
XFILLER_64_152 VGND VGND VPWR VPWR sky130_fd_sc_hd__decap_3
XFILLER_65_697 VGND VGND VPWR VPWR sky130_fd_sc_hd__decap_3
XTAP_TAPCELL_ROW_48_895 VGND VPWR sky130_fd_sc_hd__tapvpwrvgnd_1
XFILLER_64_174 VGND VGND VPWR VPWR sky130_fd_sc_hd__decap_3
XFILLER_80_634 VGND VGND VPWR VPWR sky130_fd_sc_hd__decap_3
XFILLER_80_645 VGND VGND VPWR VPWR sky130_fd_sc_hd__decap_3
X_4924_ _4920_/A _4922_/X _4923_/Y VGND VGND VPWR VPWR _4924_/X sky130_fd_sc_hd__a21o_2
XFILLER_80_678 VGND VGND VPWR VPWR sky130_fd_sc_hd__decap_3
XFILLER_33_572 VGND VGND VPWR VPWR sky130_fd_sc_hd__decap_3
XFILLER_21_712 VGND VGND VPWR VPWR sky130_fd_sc_hd__decap_3
XFILLER_20_200 VGND VGND VPWR VPWR sky130_fd_sc_hd__decap_3
X_4855_ _4855_/A _4855_/B _4854_/X VGND VGND VPWR VPWR _5655_/D sky130_fd_sc_hd__or3b_4
XFILLER_60_380 VGND VGND VPWR VPWR sky130_fd_sc_hd__fill_1
XFILLER_20_211 VGND VGND VPWR VPWR sky130_fd_sc_hd__decap_3
XPHY_EDGE_ROW_72_Left_196 VGND VGND VPWR VPWR sky130_fd_sc_hd__decap_3
X_3806_ _6966_/Q _3884_/A2 _3913_/A2 _6954_/Q _3805_/X VGND VGND VPWR VPWR _3806_/X
+ sky130_fd_sc_hd__a221o_2
XFILLER_119_600 VGND VGND VPWR VPWR sky130_fd_sc_hd__decap_3
X_4786_ _4795_/A _4795_/B _4648_/A VGND VGND VPWR VPWR _4787_/B sky130_fd_sc_hd__a21o_2
XFILLER_20_277 VGND VGND VPWR VPWR sky130_fd_sc_hd__decap_3
XFILLER_119_644 VGND VGND VPWR VPWR sky130_fd_sc_hd__decap_3
X_6525_ _6619_/A VGND VGND VPWR VPWR _6525_/Y sky130_fd_sc_hd__inv_2
XTAP_TAPCELL_ROW_95_1503 VGND VPWR sky130_fd_sc_hd__tapvpwrvgnd_1
X_3737_ _6752_/Q _3884_/A2 _3871_/B1 _6746_/Q VGND VGND VPWR VPWR _3737_/X sky130_fd_sc_hd__a22o_2
XFILLER_119_688 VGND VGND VPWR VPWR sky130_fd_sc_hd__decap_3
XFILLER_109_36 VGND VGND VPWR VPWR sky130_fd_sc_hd__decap_3
X_6456_ _6654_/A VGND VGND VPWR VPWR _6456_/Y sky130_fd_sc_hd__inv_2
X_3668_ _6943_/Q _3898_/A2 _3759_/B1 _6895_/Q VGND VGND VPWR VPWR _3668_/X sky130_fd_sc_hd__a22o_2
XFILLER_106_327 VGND VGND VPWR VPWR sky130_fd_sc_hd__fill_1
XFILLER_69_18 VGND VGND VPWR VPWR sky130_fd_sc_hd__decap_3
X_5407_ _5407_/A0 _5061_/X _5427_/S VGND VGND VPWR VPWR _7130_/D sky130_fd_sc_hd__mux2_2
X_6387_ _6387_/A VGND VGND VPWR VPWR _6387_/Y sky130_fd_sc_hd__inv_2
X_3599_ _3599_/A _3600_/A VGND VGND VPWR VPWR _4614_/C sky130_fd_sc_hd__nor2_2
XFILLER_88_701 VGND VGND VPWR VPWR sky130_fd_sc_hd__decap_3
XFILLER_0_605 VGND VGND VPWR VPWR sky130_fd_sc_hd__decap_3
X_5338_ _5338_/A0 _5061_/X _5340_/S VGND VGND VPWR VPWR _7162_/D sky130_fd_sc_hd__mux2_2
XFILLER_88_734 VGND VGND VPWR VPWR sky130_fd_sc_hd__fill_1
XFILLER_87_200 VGND VGND VPWR VPWR sky130_fd_sc_hd__decap_3
XFILLER_87_211 VGND VGND VPWR VPWR sky130_fd_sc_hd__decap_3
XFILLER_0_638 VGND VGND VPWR VPWR sky130_fd_sc_hd__decap_3
XFILLER_48_609 VGND VGND VPWR VPWR sky130_fd_sc_hd__decap_3
XFILLER_102_566 VGND VGND VPWR VPWR sky130_fd_sc_hd__decap_3
XFILLER_87_266 VGND VGND VPWR VPWR sky130_fd_sc_hd__decap_3
X_7008_ _7370_/CLK _7008_/D _6288_/Y VGND VGND VPWR VPWR _7008_/Q sky130_fd_sc_hd__dfrtp_2
XFILLER_47_119 VGND VGND VPWR VPWR sky130_fd_sc_hd__fill_1
XFILLER_18_11 VGND VGND VPWR VPWR sky130_fd_sc_hd__decap_3
XFILLER_68_480 VGND VGND VPWR VPWR sky130_fd_sc_hd__decap_3
XFILLER_18_22 VGND VGND VPWR VPWR sky130_fd_sc_hd__decap_3
XFILLER_56_631 VGND VGND VPWR VPWR sky130_fd_sc_hd__decap_3
XFILLER_28_333 VGND VGND VPWR VPWR sky130_fd_sc_hd__decap_3
XFILLER_83_461 VGND VGND VPWR VPWR sky130_fd_sc_hd__decap_3
XFILLER_71_601 VGND VGND VPWR VPWR sky130_fd_sc_hd__decap_3
XFILLER_56_675 VGND VGND VPWR VPWR sky130_fd_sc_hd__decap_3
XFILLER_18_77 VGND VGND VPWR VPWR sky130_fd_sc_hd__decap_3
XFILLER_71_623 VGND VGND VPWR VPWR sky130_fd_sc_hd__decap_3
XFILLER_43_325 VGND VGND VPWR VPWR sky130_fd_sc_hd__fill_1
XTAP_TAPCELL_ROW_104_1621 VGND VPWR sky130_fd_sc_hd__tapvpwrvgnd_1
XFILLER_71_656 VGND VGND VPWR VPWR sky130_fd_sc_hd__decap_3
XFILLER_70_144 VGND VGND VPWR VPWR sky130_fd_sc_hd__decap_3
XFILLER_12_701 VGND VGND VPWR VPWR sky130_fd_sc_hd__decap_3
XFILLER_24_572 VGND VGND VPWR VPWR sky130_fd_sc_hd__decap_3
XFILLER_70_188 VGND VGND VPWR VPWR sky130_fd_sc_hd__decap_3
XFILLER_12_734 VGND VGND VPWR VPWR sky130_fd_sc_hd__fill_1
XFILLER_11_211 VGND VGND VPWR VPWR sky130_fd_sc_hd__fill_2
XFILLER_11_233 VGND VGND VPWR VPWR sky130_fd_sc_hd__decap_3
XFILLER_8_716 VGND VGND VPWR VPWR sky130_fd_sc_hd__decap_3
XTAP_TAPCELL_ROW_115_1761 VGND VPWR sky130_fd_sc_hd__tapvpwrvgnd_1
XFILLER_79_712 VGND VGND VPWR VPWR sky130_fd_sc_hd__decap_3
XFILLER_3_476 VGND VGND VPWR VPWR sky130_fd_sc_hd__decap_3
XFILLER_78_200 VGND VGND VPWR VPWR sky130_fd_sc_hd__decap_3
XFILLER_3_498 VGND VGND VPWR VPWR sky130_fd_sc_hd__decap_3
XFILLER_105_382 VGND VGND VPWR VPWR sky130_fd_sc_hd__fill_1
XFILLER_78_233 VGND VGND VPWR VPWR sky130_fd_sc_hd__decap_3
XFILLER_94_704 VGND VGND VPWR VPWR sky130_fd_sc_hd__decap_3
XFILLER_38_108 VGND VGND VPWR VPWR sky130_fd_sc_hd__decap_3
XFILLER_120_363 VGND VGND VPWR VPWR sky130_fd_sc_hd__fill_1
XFILLER_93_203 VGND VGND VPWR VPWR sky130_fd_sc_hd__decap_3
XFILLER_120_374 VGND VGND VPWR VPWR sky130_fd_sc_hd__decap_3
XFILLER_93_225 VGND VGND VPWR VPWR sky130_fd_sc_hd__decap_3
XFILLER_78_299 VGND VGND VPWR VPWR sky130_fd_sc_hd__fill_2
XFILLER_47_620 VGND VGND VPWR VPWR sky130_fd_sc_hd__decap_3
XFILLER_115_90 VGND VGND VPWR VPWR sky130_fd_sc_hd__decap_3
XFILLER_47_653 VGND VGND VPWR VPWR sky130_fd_sc_hd__decap_3
XFILLER_19_344 VGND VGND VPWR VPWR sky130_fd_sc_hd__decap_3
XFILLER_75_72 VGND VGND VPWR VPWR sky130_fd_sc_hd__fill_2
XFILLER_46_141 VGND VGND VPWR VPWR sky130_fd_sc_hd__decap_3
XFILLER_34_303 VGND VGND VPWR VPWR sky130_fd_sc_hd__decap_3
XFILLER_19_377 VGND VGND VPWR VPWR sky130_fd_sc_hd__decap_3
XFILLER_62_623 VGND VGND VPWR VPWR sky130_fd_sc_hd__decap_3
XFILLER_47_697 VGND VGND VPWR VPWR sky130_fd_sc_hd__decap_3
XFILLER_19_388 VGND VGND VPWR VPWR sky130_fd_sc_hd__decap_3
XTAP_TAPCELL_ROW_66_1126 VGND VPWR sky130_fd_sc_hd__tapvpwrvgnd_1
XFILLER_46_185 VGND VGND VPWR VPWR sky130_fd_sc_hd__decap_3
XFILLER_19_399 VGND VGND VPWR VPWR sky130_fd_sc_hd__decap_3
XFILLER_62_645 VGND VGND VPWR VPWR sky130_fd_sc_hd__decap_3
XTAP_TAPCELL_ROW_45_854 VGND VPWR sky130_fd_sc_hd__tapvpwrvgnd_1
XFILLER_62_678 VGND VGND VPWR VPWR sky130_fd_sc_hd__decap_3
XFILLER_15_550 VGND VGND VPWR VPWR sky130_fd_sc_hd__decap_3
XFILLER_61_166 VGND VGND VPWR VPWR sky130_fd_sc_hd__fill_2
XFILLER_15_561 VGND VGND VPWR VPWR sky130_fd_sc_hd__decap_3
XFILLER_61_188 VGND VGND VPWR VPWR sky130_fd_sc_hd__decap_3
XFILLER_15_594 VGND VGND VPWR VPWR sky130_fd_sc_hd__decap_3
XFILLER_30_553 VGND VGND VPWR VPWR sky130_fd_sc_hd__decap_3
X_4640_ _4938_/B _4918_/A VGND VGND VPWR VPWR _4640_/Y sky130_fd_sc_hd__nor2_2
XFILLER_30_575 VGND VGND VPWR VPWR sky130_fd_sc_hd__decap_3
X_4571_ _4571_/A _4577_/B VGND VGND VPWR VPWR _7295_/D sky130_fd_sc_hd__and2_2
X_6310_ _6635_/A VGND VGND VPWR VPWR _6310_/Y sky130_fd_sc_hd__inv_2
X_3522_ _5118_/C _4938_/A _4764_/B VGND VGND VPWR VPWR _5020_/A sky130_fd_sc_hd__nand3_2
Xhold705 _6963_/Q VGND VGND VPWR VPWR _6963_/D sky130_fd_sc_hd__dlygate4sd3_1
XFILLER_116_625 VGND VGND VPWR VPWR sky130_fd_sc_hd__decap_3
X_7290_ _7354_/CLK _7290_/D _6570_/Y VGND VGND VPWR VPWR _7290_/Q sky130_fd_sc_hd__dfrtp_2
Xhold716 _6768_/Q VGND VGND VPWR VPWR _6768_/D sky130_fd_sc_hd__dlygate4sd3_1
Xhold727 _6813_/Q VGND VGND VPWR VPWR _6813_/D sky130_fd_sc_hd__dlygate4sd3_1
XTAP_TAPCELL_ROW_77_1266 VGND VPWR sky130_fd_sc_hd__tapvpwrvgnd_1
Xhold738 _6755_/Q VGND VGND VPWR VPWR _6755_/D sky130_fd_sc_hd__dlygate4sd3_1
Xhold749 _6821_/Q VGND VGND VPWR VPWR _6821_/D sky130_fd_sc_hd__dlygate4sd3_1
XFILLER_6_292 VGND VGND VPWR VPWR sky130_fd_sc_hd__decap_3
XFILLER_116_669 VGND VGND VPWR VPWR sky130_fd_sc_hd__decap_3
X_3453_ _7218_/Q _4307_/A2 _4346_/B1 _7378_/Q VGND VGND VPWR VPWR _3453_/X sky130_fd_sc_hd__a22o_2
XFILLER_115_146 VGND VGND VPWR VPWR sky130_fd_sc_hd__decap_3
XFILLER_103_308 VGND VGND VPWR VPWR sky130_fd_sc_hd__fill_2
XTAP_TAPCELL_ROW_90_1433 VGND VPWR sky130_fd_sc_hd__tapvpwrvgnd_1
XFILLER_97_520 VGND VGND VPWR VPWR sky130_fd_sc_hd__decap_3
X_3384_ _7315_/Q _3987_/S _4528_/B _7283_/Q VGND VGND VPWR VPWR _3384_/X sky130_fd_sc_hd__a22o_2
XFILLER_69_222 VGND VGND VPWR VPWR sky130_fd_sc_hd__fill_2
XFILLER_97_553 VGND VGND VPWR VPWR sky130_fd_sc_hd__decap_3
XFILLER_97_564 VGND VGND VPWR VPWR sky130_fd_sc_hd__decap_3
XFILLER_69_255 VGND VGND VPWR VPWR sky130_fd_sc_hd__fill_1
XFILLER_85_715 VGND VGND VPWR VPWR sky130_fd_sc_hd__decap_3
XFILLER_97_597 VGND VGND VPWR VPWR sky130_fd_sc_hd__decap_3
XFILLER_84_214 VGND VGND VPWR VPWR sky130_fd_sc_hd__decap_3
XFILLER_29_119 VGND VGND VPWR VPWR sky130_fd_sc_hd__fill_2
X_5054_ _5054_/A VGND VGND VPWR VPWR _5054_/Y sky130_fd_sc_hd__inv_2
XFILLER_57_439 VGND VGND VPWR VPWR sky130_fd_sc_hd__decap_3
XFILLER_111_385 VGND VGND VPWR VPWR sky130_fd_sc_hd__decap_3
XFILLER_111_396 VGND VGND VPWR VPWR sky130_fd_sc_hd__decap_3
XFILLER_38_631 VGND VGND VPWR VPWR sky130_fd_sc_hd__decap_3
XFILLER_84_247 VGND VGND VPWR VPWR sky130_fd_sc_hd__decap_3
XFILLER_84_269 VGND VGND VPWR VPWR sky130_fd_sc_hd__decap_3
XFILLER_37_130 VGND VGND VPWR VPWR sky130_fd_sc_hd__decap_3
XFILLER_38_675 VGND VGND VPWR VPWR sky130_fd_sc_hd__decap_3
XFILLER_53_612 VGND VGND VPWR VPWR sky130_fd_sc_hd__decap_3
XFILLER_53_623 VGND VGND VPWR VPWR sky130_fd_sc_hd__decap_3
XFILLER_25_314 VGND VGND VPWR VPWR sky130_fd_sc_hd__decap_3
XFILLER_1_91 VGND VGND VPWR VPWR sky130_fd_sc_hd__decap_3
XFILLER_92_280 VGND VGND VPWR VPWR sky130_fd_sc_hd__decap_3
XFILLER_111_15 VGND VGND VPWR VPWR sky130_fd_sc_hd__decap_3
XFILLER_53_656 VGND VGND VPWR VPWR sky130_fd_sc_hd__decap_3
XFILLER_52_144 VGND VGND VPWR VPWR sky130_fd_sc_hd__decap_3
XFILLER_111_48 VGND VGND VPWR VPWR sky130_fd_sc_hd__decap_3
XFILLER_80_464 VGND VGND VPWR VPWR sky130_fd_sc_hd__fill_2
XPHY_EDGE_ROW_80_Left_204 VGND VGND VPWR VPWR sky130_fd_sc_hd__decap_3
X_4907_ _4829_/A _4888_/B _4903_/X _4906_/X VGND VGND VPWR VPWR _4907_/Y sky130_fd_sc_hd__o31ai_4
XFILLER_40_339 VGND VGND VPWR VPWR sky130_fd_sc_hd__decap_3
XFILLER_21_586 VGND VGND VPWR VPWR sky130_fd_sc_hd__decap_3
XFILLER_119_441 VGND VGND VPWR VPWR sky130_fd_sc_hd__decap_3
X_4769_ _4969_/B _4741_/X _4761_/Y _4768_/Y VGND VGND VPWR VPWR _5663_/A sky130_fd_sc_hd__a31o_2
XFILLER_119_463 VGND VGND VPWR VPWR sky130_fd_sc_hd__decap_3
XFILLER_107_603 VGND VGND VPWR VPWR sky130_fd_sc_hd__decap_3
X_6508_ _6542_/A VGND VGND VPWR VPWR _6508_/Y sky130_fd_sc_hd__inv_2
XFILLER_4_218 VGND VGND VPWR VPWR sky130_fd_sc_hd__decap_3
XFILLER_119_496 VGND VGND VPWR VPWR sky130_fd_sc_hd__decap_3
XFILLER_107_647 VGND VGND VPWR VPWR sky130_fd_sc_hd__decap_3
XFILLER_105_6 VGND VGND VPWR VPWR sky130_fd_sc_hd__decap_3
X_6439_ _6632_/A VGND VGND VPWR VPWR _6439_/Y sky130_fd_sc_hd__inv_2
XFILLER_122_628 VGND VGND VPWR VPWR sky130_fd_sc_hd__decap_3
XFILLER_0_402 VGND VGND VPWR VPWR sky130_fd_sc_hd__decap_3
XFILLER_121_105 VGND VGND VPWR VPWR sky130_fd_sc_hd__decap_3
XFILLER_0_413 VGND VGND VPWR VPWR sky130_fd_sc_hd__decap_3
XFILLER_121_116 VGND VGND VPWR VPWR sky130_fd_sc_hd__decap_3
XFILLER_0_424 VGND VGND VPWR VPWR sky130_fd_sc_hd__fill_1
XFILLER_115_691 VGND VGND VPWR VPWR sky130_fd_sc_hd__decap_3
XFILLER_0_446 VGND VGND VPWR VPWR sky130_fd_sc_hd__fill_2
XFILLER_88_553 VGND VGND VPWR VPWR sky130_fd_sc_hd__decap_3
XFILLER_76_704 VGND VGND VPWR VPWR sky130_fd_sc_hd__decap_3
XFILLER_48_406 VGND VGND VPWR VPWR sky130_fd_sc_hd__decap_3
XFILLER_88_586 VGND VGND VPWR VPWR sky130_fd_sc_hd__fill_2
XFILLER_102_374 VGND VGND VPWR VPWR sky130_fd_sc_hd__decap_3
XTAP_TAPCELL_ROW_110_1691 VGND VPWR sky130_fd_sc_hd__tapvpwrvgnd_1
XFILLER_75_225 VGND VGND VPWR VPWR sky130_fd_sc_hd__decap_3
XFILLER_29_76 VGND VGND VPWR VPWR sky130_fd_sc_hd__decap_3
XFILLER_29_620 VGND VGND VPWR VPWR sky130_fd_sc_hd__decap_3
XFILLER_75_236 VGND VGND VPWR VPWR sky130_fd_sc_hd__decap_3
XFILLER_91_718 VGND VGND VPWR VPWR sky130_fd_sc_hd__decap_3
XFILLER_29_653 VGND VGND VPWR VPWR sky130_fd_sc_hd__decap_3
XFILLER_28_141 VGND VGND VPWR VPWR sky130_fd_sc_hd__decap_3
XFILLER_91_729 VGND VGND VPWR VPWR sky130_fd_sc_hd__decap_3
XFILLER_90_217 VGND VGND VPWR VPWR sky130_fd_sc_hd__decap_3
XFILLER_44_612 VGND VGND VPWR VPWR sky130_fd_sc_hd__decap_3
Xplace409 _3562_/A VGND VGND VPWR VPWR _3488_/B sky130_fd_sc_hd__buf_2
XFILLER_29_697 VGND VGND VPWR VPWR sky130_fd_sc_hd__decap_3
XFILLER_56_483 VGND VGND VPWR VPWR sky130_fd_sc_hd__decap_3
XPHY_EDGE_ROW_119_Left_243 VGND VGND VPWR VPWR sky130_fd_sc_hd__decap_3
XFILLER_71_420 VGND VGND VPWR VPWR sky130_fd_sc_hd__decap_3
XFILLER_44_645 VGND VGND VPWR VPWR sky130_fd_sc_hd__decap_3
XFILLER_16_336 VGND VGND VPWR VPWR sky130_fd_sc_hd__decap_3
XFILLER_16_358 VGND VGND VPWR VPWR sky130_fd_sc_hd__decap_3
XFILLER_44_678 VGND VGND VPWR VPWR sky130_fd_sc_hd__decap_3
XTAP_TAPCELL_ROW_42_813 VGND VPWR sky130_fd_sc_hd__tapvpwrvgnd_1
XFILLER_43_177 VGND VGND VPWR VPWR sky130_fd_sc_hd__fill_2
XFILLER_31_317 VGND VGND VPWR VPWR sky130_fd_sc_hd__decap_3
XFILLER_61_41 VGND VGND VPWR VPWR sky130_fd_sc_hd__fill_2
XFILLER_12_553 VGND VGND VPWR VPWR sky130_fd_sc_hd__decap_3
XTAP_TAPCELL_ROW_61_1056 VGND VPWR sky130_fd_sc_hd__tapvpwrvgnd_1
XFILLER_8_513 VGND VGND VPWR VPWR sky130_fd_sc_hd__decap_3
XFILLER_61_52 VGND VGND VPWR VPWR sky130_fd_sc_hd__decap_3
XFILLER_12_586 VGND VGND VPWR VPWR sky130_fd_sc_hd__fill_2
XFILLER_8_557 VGND VGND VPWR VPWR sky130_fd_sc_hd__decap_3
XANTENNA_7 _3331_/A VGND VGND VPWR VPWR sky130_fd_sc_hd__diode_2
XFILLER_113_606 VGND VGND VPWR VPWR sky130_fd_sc_hd__decap_3
XFILLER_113_617 VGND VGND VPWR VPWR sky130_fd_sc_hd__decap_3
XFILLER_79_564 VGND VGND VPWR VPWR sky130_fd_sc_hd__decap_3
XFILLER_121_650 VGND VGND VPWR VPWR sky130_fd_sc_hd__decap_3
XFILLER_67_715 VGND VGND VPWR VPWR sky130_fd_sc_hd__decap_3
XFILLER_79_597 VGND VGND VPWR VPWR sky130_fd_sc_hd__decap_3
XFILLER_66_225 VGND VGND VPWR VPWR sky130_fd_sc_hd__decap_3
XFILLER_39_439 VGND VGND VPWR VPWR sky130_fd_sc_hd__decap_3
XFILLER_121_694 VGND VGND VPWR VPWR sky130_fd_sc_hd__decap_3
XFILLER_94_556 VGND VGND VPWR VPWR sky130_fd_sc_hd__decap_3
XFILLER_82_707 VGND VGND VPWR VPWR sky130_fd_sc_hd__decap_3
XFILLER_94_589 VGND VGND VPWR VPWR sky130_fd_sc_hd__decap_3
XFILLER_81_217 VGND VGND VPWR VPWR sky130_fd_sc_hd__decap_3
XFILLER_35_612 VGND VGND VPWR VPWR sky130_fd_sc_hd__decap_3
XFILLER_81_228 VGND VGND VPWR VPWR sky130_fd_sc_hd__decap_3
XFILLER_35_623 VGND VGND VPWR VPWR sky130_fd_sc_hd__decap_3
XFILLER_19_185 VGND VGND VPWR VPWR sky130_fd_sc_hd__fill_2
XFILLER_62_442 VGND VGND VPWR VPWR sky130_fd_sc_hd__decap_3
XFILLER_35_656 VGND VGND VPWR VPWR sky130_fd_sc_hd__decap_3
XFILLER_50_604 VGND VGND VPWR VPWR sky130_fd_sc_hd__decap_3
X_6790_ clkload9/A _6790_/D VGND VGND VPWR VPWR _6790_/Q sky130_fd_sc_hd__dfxtp_2
XFILLER_22_306 VGND VGND VPWR VPWR sky130_fd_sc_hd__fill_2
XFILLER_62_475 VGND VGND VPWR VPWR sky130_fd_sc_hd__fill_1
XFILLER_34_177 VGND VGND VPWR VPWR sky130_fd_sc_hd__decap_3
XFILLER_50_637 VGND VGND VPWR VPWR sky130_fd_sc_hd__decap_3
XFILLER_22_328 VGND VGND VPWR VPWR sky130_fd_sc_hd__decap_3
XFILLER_50_648 VGND VGND VPWR VPWR sky130_fd_sc_hd__decap_3
XFILLER_30_361 VGND VGND VPWR VPWR sky130_fd_sc_hd__decap_3
XTAP_TAPCELL_ROW_20_529 VGND VPWR sky130_fd_sc_hd__tapvpwrvgnd_1
XFILLER_30_383 VGND VGND VPWR VPWR sky130_fd_sc_hd__decap_3
X_4623_ _4330_/B _4622_/X _5057_/B VGND VGND VPWR VPWR _4624_/A sky130_fd_sc_hd__o21ba_2
X_7342_ _7374_/CLK _7342_/D _6622_/Y VGND VGND VPWR VPWR _7342_/Q sky130_fd_sc_hd__dfrtp_2
X_4554_ _4554_/A _4559_/B VGND VGND VPWR VPWR _7303_/D sky130_fd_sc_hd__and2_2
X_3505_ _3505_/A _3505_/B VGND VGND VPWR VPWR _3505_/X sky130_fd_sc_hd__or2_4
X_7273_ _7372_/CLK _7273_/D _6553_/Y VGND VGND VPWR VPWR _7273_/Q sky130_fd_sc_hd__dfrtp_2
XFILLER_116_466 VGND VGND VPWR VPWR sky130_fd_sc_hd__decap_3
XFILLER_116_488 VGND VGND VPWR VPWR sky130_fd_sc_hd__decap_3
XFILLER_104_628 VGND VGND VPWR VPWR sky130_fd_sc_hd__decap_3
XFILLER_106_15 VGND VGND VPWR VPWR sky130_fd_sc_hd__decap_3
XFILLER_58_704 VGND VGND VPWR VPWR sky130_fd_sc_hd__decap_3
XFILLER_97_361 VGND VGND VPWR VPWR sky130_fd_sc_hd__decap_3
XFILLER_85_501 VGND VGND VPWR VPWR sky130_fd_sc_hd__decap_3
XFILLER_112_672 VGND VGND VPWR VPWR sky130_fd_sc_hd__decap_3
Xhold1202 _7308_/Q VGND VGND VPWR VPWR _4544_/A sky130_fd_sc_hd__dlygate4sd3_1
XFILLER_57_203 VGND VGND VPWR VPWR sky130_fd_sc_hd__decap_3
X_5106_ _6985_/Q _5068_/C _5581_/S VGND VGND VPWR VPWR _5106_/X sky130_fd_sc_hd__o21a_2
Xhold1213 _7358_/Q VGND VGND VPWR VPWR _3964_/A0 sky130_fd_sc_hd__dlygate4sd3_1
XFILLER_57_225 VGND VGND VPWR VPWR sky130_fd_sc_hd__decap_3
XFILLER_85_556 VGND VGND VPWR VPWR sky130_fd_sc_hd__decap_3
XFILLER_111_193 VGND VGND VPWR VPWR sky130_fd_sc_hd__fill_1
XFILLER_85_567 VGND VGND VPWR VPWR sky130_fd_sc_hd__decap_3
XFILLER_57_258 VGND VGND VPWR VPWR sky130_fd_sc_hd__decap_3
X_5037_ _6988_/Q _5045_/B VGND VGND VPWR VPWR _5038_/B sky130_fd_sc_hd__nand2_2
XFILLER_73_718 VGND VGND VPWR VPWR sky130_fd_sc_hd__decap_3
XFILLER_57_269 VGND VGND VPWR VPWR sky130_fd_sc_hd__decap_3
XFILLER_122_14 VGND VGND VPWR VPWR sky130_fd_sc_hd__decap_3
XFILLER_73_729 VGND VGND VPWR VPWR sky130_fd_sc_hd__decap_3
XFILLER_26_601 VGND VGND VPWR VPWR sky130_fd_sc_hd__decap_3
XTAP_TAPCELL_ROW_28_629 VGND VPWR sky130_fd_sc_hd__tapvpwrvgnd_1
XFILLER_122_47 VGND VGND VPWR VPWR sky130_fd_sc_hd__decap_3
XFILLER_72_239 VGND VGND VPWR VPWR sky130_fd_sc_hd__decap_3
XFILLER_26_634 VGND VGND VPWR VPWR sky130_fd_sc_hd__decap_3
XFILLER_82_18 VGND VGND VPWR VPWR sky130_fd_sc_hd__decap_3
XFILLER_26_645 VGND VGND VPWR VPWR sky130_fd_sc_hd__decap_3
XTAP_TAPCELL_ROW_0_254 VGND VPWR sky130_fd_sc_hd__tapvpwrvgnd_1
XFILLER_82_29 VGND VGND VPWR VPWR sky130_fd_sc_hd__decap_3
XTAP_TAPCELL_ROW_0_265 VGND VPWR sky130_fd_sc_hd__tapvpwrvgnd_1
XFILLER_41_604 VGND VGND VPWR VPWR sky130_fd_sc_hd__decap_3
XFILLER_26_678 VGND VGND VPWR VPWR sky130_fd_sc_hd__decap_3
X_6988_ _7386_/CLK _6988_/D _6268_/Y VGND VGND VPWR VPWR _6988_/Q sky130_fd_sc_hd__dfrtp_2
XFILLER_41_626 VGND VGND VPWR VPWR sky130_fd_sc_hd__decap_3
XFILLER_53_497 VGND VGND VPWR VPWR sky130_fd_sc_hd__decap_3
XFILLER_25_188 VGND VGND VPWR VPWR sky130_fd_sc_hd__decap_3
XFILLER_80_283 VGND VGND VPWR VPWR sky130_fd_sc_hd__decap_3
XFILLER_41_659 VGND VGND VPWR VPWR sky130_fd_sc_hd__decap_3
XFILLER_21_350 VGND VGND VPWR VPWR sky130_fd_sc_hd__decap_3
XFILLER_31_11 VGND VGND VPWR VPWR sky130_fd_sc_hd__fill_1
XFILLER_5_505 VGND VGND VPWR VPWR sky130_fd_sc_hd__fill_1
XFILLER_5_549 VGND VGND VPWR VPWR sky130_fd_sc_hd__decap_3
XFILLER_107_466 VGND VGND VPWR VPWR sky130_fd_sc_hd__decap_3
XFILLER_103_3 VGND VGND VPWR VPWR sky130_fd_sc_hd__decap_3
XFILLER_1_700 VGND VGND VPWR VPWR sky130_fd_sc_hd__decap_3
XTAP_TAPCELL_ROW_112_1720 VGND VPWR sky130_fd_sc_hd__tapvpwrvgnd_1
XFILLER_1_711 VGND VGND VPWR VPWR sky130_fd_sc_hd__decap_3
XFILLER_122_447 VGND VGND VPWR VPWR sky130_fd_sc_hd__decap_3
XFILLER_0_221 VGND VGND VPWR VPWR sky130_fd_sc_hd__decap_3
XTAP_TAPCELL_ROW_8_365 VGND VPWR sky130_fd_sc_hd__tapvpwrvgnd_1
XTAP_TAPCELL_ROW_8_376 VGND VPWR sky130_fd_sc_hd__tapvpwrvgnd_1
XFILLER_103_650 VGND VGND VPWR VPWR sky130_fd_sc_hd__decap_3
XFILLER_88_350 VGND VGND VPWR VPWR sky130_fd_sc_hd__decap_3
XFILLER_49_715 VGND VGND VPWR VPWR sky130_fd_sc_hd__decap_3
XFILLER_88_383 VGND VGND VPWR VPWR sky130_fd_sc_hd__fill_1
XFILLER_103_694 VGND VGND VPWR VPWR sky130_fd_sc_hd__decap_3
XFILLER_102_182 VGND VGND VPWR VPWR sky130_fd_sc_hd__decap_3
XFILLER_64_707 VGND VGND VPWR VPWR sky130_fd_sc_hd__decap_3
XFILLER_56_52 VGND VGND VPWR VPWR sky130_fd_sc_hd__fill_2
XFILLER_17_612 VGND VGND VPWR VPWR sky130_fd_sc_hd__decap_3
XFILLER_56_85 VGND VGND VPWR VPWR sky130_fd_sc_hd__fill_2
XFILLER_29_483 VGND VGND VPWR VPWR sky130_fd_sc_hd__decap_3
XFILLER_17_623 VGND VGND VPWR VPWR sky130_fd_sc_hd__decap_3
XFILLER_16_111 VGND VGND VPWR VPWR sky130_fd_sc_hd__decap_3
XFILLER_91_559 VGND VGND VPWR VPWR sky130_fd_sc_hd__fill_1
XFILLER_17_656 VGND VGND VPWR VPWR sky130_fd_sc_hd__decap_3
XFILLER_44_442 VGND VGND VPWR VPWR sky130_fd_sc_hd__decap_3
XFILLER_16_133 VGND VGND VPWR VPWR sky130_fd_sc_hd__decap_3
XFILLER_32_604 VGND VGND VPWR VPWR sky130_fd_sc_hd__decap_3
XFILLER_16_155 VGND VGND VPWR VPWR sky130_fd_sc_hd__decap_3
XFILLER_44_475 VGND VGND VPWR VPWR sky130_fd_sc_hd__fill_1
XTAP_TAPCELL_ROW_123_1860 VGND VPWR sky130_fd_sc_hd__tapvpwrvgnd_1
XTAP_TAPCELL_ROW_55_982 VGND VPWR sky130_fd_sc_hd__tapvpwrvgnd_1
XFILLER_32_637 VGND VGND VPWR VPWR sky130_fd_sc_hd__decap_3
XFILLER_31_103 VGND VGND VPWR VPWR sky130_fd_sc_hd__decap_3
XTAP_TAPCELL_ROW_123_1871 VGND VPWR sky130_fd_sc_hd__tapvpwrvgnd_1
XTAP_TAPCELL_ROW_123_1882 VGND VPWR sky130_fd_sc_hd__tapvpwrvgnd_1
XFILLER_32_648 VGND VGND VPWR VPWR sky130_fd_sc_hd__decap_3
XFILLER_31_169 VGND VGND VPWR VPWR sky130_fd_sc_hd__fill_1
XFILLER_12_361 VGND VGND VPWR VPWR sky130_fd_sc_hd__decap_3
XFILLER_40_681 VGND VGND VPWR VPWR sky130_fd_sc_hd__decap_3
XFILLER_8_376 VGND VGND VPWR VPWR sky130_fd_sc_hd__decap_3
XFILLER_8_398 VGND VGND VPWR VPWR sky130_fd_sc_hd__decap_3
XFILLER_99_615 VGND VGND VPWR VPWR sky130_fd_sc_hd__fill_1
XTAP_TAPCELL_ROW_74_1225 VGND VPWR sky130_fd_sc_hd__tapvpwrvgnd_1
XFILLER_99_626 VGND VGND VPWR VPWR sky130_fd_sc_hd__decap_3
XFILLER_4_560 VGND VGND VPWR VPWR sky130_fd_sc_hd__decap_3
X_4270_ _7358_/Q _4270_/B VGND VGND VPWR VPWR _4270_/Y sky130_fd_sc_hd__nand2_2
XFILLER_99_659 VGND VGND VPWR VPWR sky130_fd_sc_hd__decap_3
XFILLER_113_447 VGND VGND VPWR VPWR sky130_fd_sc_hd__fill_1
XFILLER_101_609 VGND VGND VPWR VPWR sky130_fd_sc_hd__decap_3
XFILLER_98_169 VGND VGND VPWR VPWR sky130_fd_sc_hd__decap_3
XFILLER_79_361 VGND VGND VPWR VPWR sky130_fd_sc_hd__decap_3
XFILLER_39_225 VGND VGND VPWR VPWR sky130_fd_sc_hd__decap_3
XFILLER_121_491 VGND VGND VPWR VPWR sky130_fd_sc_hd__decap_3
XFILLER_67_556 VGND VGND VPWR VPWR sky130_fd_sc_hd__decap_3
XFILLER_39_258 VGND VGND VPWR VPWR sky130_fd_sc_hd__decap_3
XFILLER_82_504 VGND VGND VPWR VPWR sky130_fd_sc_hd__decap_3
XFILLER_55_718 VGND VGND VPWR VPWR sky130_fd_sc_hd__decap_3
XFILLER_39_269 VGND VGND VPWR VPWR sky130_fd_sc_hd__fill_2
XFILLER_55_729 VGND VGND VPWR VPWR sky130_fd_sc_hd__decap_3
XFILLER_54_217 VGND VGND VPWR VPWR sky130_fd_sc_hd__decap_3
X_6911_ clkload8/A _6911_/D VGND VGND VPWR VPWR _6911_/Q sky130_fd_sc_hd__dfxtp_2
XFILLER_82_559 VGND VGND VPWR VPWR sky130_fd_sc_hd__decap_3
XFILLER_23_604 VGND VGND VPWR VPWR sky130_fd_sc_hd__decap_3
X_6842_ _6978_/CLK _6842_/D VGND VGND VPWR VPWR _6842_/Q sky130_fd_sc_hd__dfxtp_2
XFILLER_62_250 VGND VGND VPWR VPWR sky130_fd_sc_hd__fill_2
XTAP_TAPCELL_ROW_85_1376 VGND VPWR sky130_fd_sc_hd__tapvpwrvgnd_1
XFILLER_23_626 VGND VGND VPWR VPWR sky130_fd_sc_hd__decap_3
XFILLER_90_581 VGND VGND VPWR VPWR sky130_fd_sc_hd__decap_3
XFILLER_90_592 VGND VGND VPWR VPWR sky130_fd_sc_hd__decap_3
X_6773_ _6967_/CLK _6773_/D VGND VGND VPWR VPWR _6773_/Q sky130_fd_sc_hd__dfxtp_2
XFILLER_23_659 VGND VGND VPWR VPWR sky130_fd_sc_hd__decap_3
X_3985_ _7348_/Q _4526_/A0 _3987_/S VGND VGND VPWR VPWR _7348_/D sky130_fd_sc_hd__mux2_2
XFILLER_50_445 VGND VGND VPWR VPWR sky130_fd_sc_hd__decap_3
XFILLER_50_489 VGND VGND VPWR VPWR sky130_fd_sc_hd__fill_1
XTAP_TAPCELL_ROW_33_698 VGND VPWR sky130_fd_sc_hd__tapvpwrvgnd_1
XFILLER_109_709 VGND VGND VPWR VPWR sky130_fd_sc_hd__decap_3
X_5655_ _5655_/A _5655_/B _5655_/C _5655_/D VGND VGND VPWR VPWR _5665_/B sky130_fd_sc_hd__nor4_2
XFILLER_108_208 VGND VGND VPWR VPWR sky130_fd_sc_hd__decap_3
X_4606_ _5666_/A _4671_/B VGND VGND VPWR VPWR _5092_/C sky130_fd_sc_hd__nor2_2
X_5586_ hold962/X _5595_/B _5118_/X VGND VGND VPWR VPWR _7035_/D sky130_fd_sc_hd__o21a_2
X_7325_ _7325_/CLK _7325_/D _6605_/Y VGND VGND VPWR VPWR _7325_/Q sky130_fd_sc_hd__dfrtp_2
X_4537_ _5118_/A _4537_/B _4537_/C VGND VGND VPWR VPWR _4537_/X sky130_fd_sc_hd__or3_2
XFILLER_2_519 VGND VGND VPWR VPWR sky130_fd_sc_hd__decap_3
XFILLER_89_103 VGND VGND VPWR VPWR sky130_fd_sc_hd__fill_1
XFILLER_117_36 VGND VGND VPWR VPWR sky130_fd_sc_hd__decap_3
XFILLER_116_274 VGND VGND VPWR VPWR sky130_fd_sc_hd__decap_3
X_7256_ _7345_/CLK _7256_/D _6536_/Y VGND VGND VPWR VPWR _7256_/Q sky130_fd_sc_hd__dfrtp_2
X_4468_ _7009_/Q _5152_/B _5581_/S VGND VGND VPWR VPWR _4468_/X sky130_fd_sc_hd__o21a_2
XFILLER_89_136 VGND VGND VPWR VPWR sky130_fd_sc_hd__decap_3
XFILLER_104_436 VGND VGND VPWR VPWR sky130_fd_sc_hd__decap_3
XFILLER_77_18 VGND VGND VPWR VPWR sky130_fd_sc_hd__decap_3
XFILLER_117_69 VGND VGND VPWR VPWR sky130_fd_sc_hd__decap_3
X_3419_ _7123_/Q _4351_/B1 _3413_/X _3418_/X VGND VGND VPWR VPWR _3419_/Y sky130_fd_sc_hd__a211oi_2
XFILLER_89_169 VGND VGND VPWR VPWR sky130_fd_sc_hd__decap_3
X_7187_ _7387_/CLK _7187_/D _6467_/Y VGND VGND VPWR VPWR _7187_/Q sky130_fd_sc_hd__dfrtp_2
X_4399_ _7370_/Q _4399_/A2 _4398_/X _4429_/C1 VGND VGND VPWR VPWR _4399_/X sky130_fd_sc_hd__a211o_2
XFILLER_98_681 VGND VGND VPWR VPWR sky130_fd_sc_hd__decap_3
XFILLER_58_512 VGND VGND VPWR VPWR sky130_fd_sc_hd__decap_3
XTAP_TAPCELL_ROW_5_335 VGND VPWR sky130_fd_sc_hd__tapvpwrvgnd_1
XFILLER_112_480 VGND VGND VPWR VPWR sky130_fd_sc_hd__decap_3
Xhold1010 _7233_/Q VGND VGND VPWR VPWR _5190_/A sky130_fd_sc_hd__dlygate4sd3_1
XFILLER_85_320 VGND VGND VPWR VPWR sky130_fd_sc_hd__decap_3
XFILLER_100_631 VGND VGND VPWR VPWR sky130_fd_sc_hd__decap_3
Xhold1021 _7261_/Q VGND VGND VPWR VPWR _5012_/A0 sky130_fd_sc_hd__dlygate4sd3_1
Xhold1032 _7013_/Q VGND VGND VPWR VPWR _5630_/A sky130_fd_sc_hd__dlygate4sd3_1
XFILLER_58_567 VGND VGND VPWR VPWR sky130_fd_sc_hd__decap_3
XFILLER_46_707 VGND VGND VPWR VPWR sky130_fd_sc_hd__decap_3
Xhold1043 _7195_/Q VGND VGND VPWR VPWR _5270_/A0 sky130_fd_sc_hd__dlygate4sd3_1
XFILLER_18_409 VGND VGND VPWR VPWR sky130_fd_sc_hd__fill_1
Xhold1054 _7242_/Q VGND VGND VPWR VPWR _5171_/A sky130_fd_sc_hd__dlygate4sd3_1
XFILLER_58_589 VGND VGND VPWR VPWR sky130_fd_sc_hd__decap_3
XFILLER_100_675 VGND VGND VPWR VPWR sky130_fd_sc_hd__decap_3
Xhold1065 _4599_/X VGND VGND VPWR VPWR _7281_/D sky130_fd_sc_hd__dlygate4sd3_1
Xhold1076 _7232_/Q VGND VGND VPWR VPWR _5192_/A sky130_fd_sc_hd__dlygate4sd3_1
XFILLER_85_386 VGND VGND VPWR VPWR sky130_fd_sc_hd__decap_3
XFILLER_45_217 VGND VGND VPWR VPWR sky130_fd_sc_hd__decap_3
Xhold1087 _7129_/Q VGND VGND VPWR VPWR _5409_/A0 sky130_fd_sc_hd__dlygate4sd3_1
Xhold1098 _7139_/Q VGND VGND VPWR VPWR _5388_/A0 sky130_fd_sc_hd__dlygate4sd3_1
XFILLER_73_559 VGND VGND VPWR VPWR sky130_fd_sc_hd__fill_1
XFILLER_38_280 VGND VGND VPWR VPWR sky130_fd_sc_hd__decap_3
XFILLER_26_431 VGND VGND VPWR VPWR sky130_fd_sc_hd__decap_3
XFILLER_60_209 VGND VGND VPWR VPWR sky130_fd_sc_hd__decap_3
XFILLER_14_604 VGND VGND VPWR VPWR sky130_fd_sc_hd__decap_3
XFILLER_81_570 VGND VGND VPWR VPWR sky130_fd_sc_hd__decap_3
XFILLER_26_88 VGND VGND VPWR VPWR sky130_fd_sc_hd__decap_3
XFILLER_26_486 VGND VGND VPWR VPWR sky130_fd_sc_hd__fill_1
XFILLER_14_637 VGND VGND VPWR VPWR sky130_fd_sc_hd__decap_3
XFILLER_14_648 VGND VGND VPWR VPWR sky130_fd_sc_hd__decap_3
XTAP_TAPCELL_ROW_52_941 VGND VPWR sky130_fd_sc_hd__tapvpwrvgnd_1
XFILLER_13_136 VGND VGND VPWR VPWR sky130_fd_sc_hd__decap_3
XFILLER_22_681 VGND VGND VPWR VPWR sky130_fd_sc_hd__decap_3
XFILLER_5_302 VGND VGND VPWR VPWR sky130_fd_sc_hd__decap_3
XFILLER_5_324 VGND VGND VPWR VPWR sky130_fd_sc_hd__decap_3
XFILLER_108_731 VGND VGND VPWR VPWR sky130_fd_sc_hd__decap_3
XFILLER_5_335 VGND VGND VPWR VPWR sky130_fd_sc_hd__fill_1
XFILLER_123_701 VGND VGND VPWR VPWR sky130_fd_sc_hd__decap_3
XFILLER_107_252 VGND VGND VPWR VPWR sky130_fd_sc_hd__decap_3
XFILLER_122_200 VGND VGND VPWR VPWR sky130_fd_sc_hd__fill_2
XFILLER_96_607 VGND VGND VPWR VPWR sky130_fd_sc_hd__decap_3
XFILLER_3_26 VGND VGND VPWR VPWR sky130_fd_sc_hd__decap_3
XFILLER_1_541 VGND VGND VPWR VPWR sky130_fd_sc_hd__decap_3
XFILLER_68_309 VGND VGND VPWR VPWR sky130_fd_sc_hd__decap_3
XFILLER_110_406 VGND VGND VPWR VPWR sky130_fd_sc_hd__fill_2
XFILLER_1_585 VGND VGND VPWR VPWR sky130_fd_sc_hd__decap_3
XFILLER_67_51 VGND VGND VPWR VPWR sky130_fd_sc_hd__decap_3
XFILLER_76_320 VGND VGND VPWR VPWR sky130_fd_sc_hd__decap_3
XFILLER_49_534 VGND VGND VPWR VPWR sky130_fd_sc_hd__decap_3
XFILLER_76_342 VGND VGND VPWR VPWR sky130_fd_sc_hd__decap_3
XFILLER_37_718 VGND VGND VPWR VPWR sky130_fd_sc_hd__decap_3
XFILLER_37_729 VGND VGND VPWR VPWR sky130_fd_sc_hd__decap_3
XFILLER_36_206 VGND VGND VPWR VPWR sky130_fd_sc_hd__decap_3
XFILLER_91_334 VGND VGND VPWR VPWR sky130_fd_sc_hd__fill_2
XFILLER_91_389 VGND VGND VPWR VPWR sky130_fd_sc_hd__decap_3
XFILLER_60_710 VGND VGND VPWR VPWR sky130_fd_sc_hd__decap_3
XFILLER_83_83 VGND VGND VPWR VPWR sky130_fd_sc_hd__decap_3
XFILLER_83_94 VGND VGND VPWR VPWR sky130_fd_sc_hd__decap_3
XFILLER_72_592 VGND VGND VPWR VPWR sky130_fd_sc_hd__decap_3
XFILLER_20_607 VGND VGND VPWR VPWR sky130_fd_sc_hd__decap_3
X_3770_ hold970/X _3857_/A2 _4944_/B VGND VGND VPWR VPWR _7393_/D sky130_fd_sc_hd__a21o_2
XFILLER_32_489 VGND VGND VPWR VPWR sky130_fd_sc_hd__decap_3
XFILLER_9_641 VGND VGND VPWR VPWR sky130_fd_sc_hd__decap_3
XFILLER_12_180 VGND VGND VPWR VPWR sky130_fd_sc_hd__decap_3
XTAP_TAPCELL_ROW_30_657 VGND VPWR sky130_fd_sc_hd__tapvpwrvgnd_1
XFILLER_118_528 VGND VGND VPWR VPWR sky130_fd_sc_hd__decap_3
XFILLER_9_685 VGND VGND VPWR VPWR sky130_fd_sc_hd__decap_3
XFILLER_118_539 VGND VGND VPWR VPWR sky130_fd_sc_hd__decap_3
XFILLER_66_3 VGND VGND VPWR VPWR sky130_fd_sc_hd__decap_3
X_5371_ _5371_/A0 _4771_/X _5383_/S VGND VGND VPWR VPWR _7147_/D sky130_fd_sc_hd__mux2_2
XFILLER_114_701 VGND VGND VPWR VPWR sky130_fd_sc_hd__decap_3
XTAP_TAPCELL_ROW_10_392 VGND VPWR sky130_fd_sc_hd__tapvpwrvgnd_1
X_7110_ _7374_/CLK _7110_/D _6390_/Y VGND VGND VPWR VPWR _7110_/Q sky130_fd_sc_hd__dfrtp_2
X_4322_ _7290_/Q _5080_/S _4352_/B1 _7162_/Q _4321_/X VGND VGND VPWR VPWR _4322_/X
+ sky130_fd_sc_hd__a221o_2
XFILLER_114_734 VGND VGND VPWR VPWR sky130_fd_sc_hd__fill_1
XFILLER_99_456 VGND VGND VPWR VPWR sky130_fd_sc_hd__fill_2
XFILLER_99_467 VGND VGND VPWR VPWR sky130_fd_sc_hd__fill_2
XFILLER_4_390 VGND VGND VPWR VPWR sky130_fd_sc_hd__fill_2
X_7041_ _7401_/CLK _7041_/D _6321_/Y VGND VGND VPWR VPWR _7041_/Q sky130_fd_sc_hd__dfrtp_2
X_4253_ _7389_/Q _4268_/B1 _5028_/S _7293_/Q _4252_/X VGND VGND VPWR VPWR _4253_/X
+ sky130_fd_sc_hd__a221o_2
XFILLER_87_629 VGND VGND VPWR VPWR sky130_fd_sc_hd__decap_3
XFILLER_86_117 VGND VGND VPWR VPWR sky130_fd_sc_hd__decap_3
XFILLER_101_428 VGND VGND VPWR VPWR sky130_fd_sc_hd__decap_3
X_4184_ _7296_/Q _5028_/S _4351_/A2 _7104_/Q _4183_/X VGND VGND VPWR VPWR _4185_/C
+ sky130_fd_sc_hd__a221o_2
XFILLER_28_707 VGND VGND VPWR VPWR sky130_fd_sc_hd__decap_3
XFILLER_95_662 VGND VGND VPWR VPWR sky130_fd_sc_hd__decap_3
XFILLER_95_673 VGND VGND VPWR VPWR sky130_fd_sc_hd__decap_3
XFILLER_27_206 VGND VGND VPWR VPWR sky130_fd_sc_hd__decap_3
XFILLER_82_312 VGND VGND VPWR VPWR sky130_fd_sc_hd__decap_3
XFILLER_55_537 VGND VGND VPWR VPWR sky130_fd_sc_hd__decap_3
XFILLER_27_228 VGND VGND VPWR VPWR sky130_fd_sc_hd__decap_3
XFILLER_103_27 VGND VGND VPWR VPWR sky130_fd_sc_hd__decap_3
XFILLER_103_49 VGND VGND VPWR VPWR sky130_fd_sc_hd__decap_3
XTAP_TAPCELL_ROW_38_757 VGND VPWR sky130_fd_sc_hd__tapvpwrvgnd_1
XFILLER_42_209 VGND VGND VPWR VPWR sky130_fd_sc_hd__decap_3
XFILLER_63_570 VGND VGND VPWR VPWR sky130_fd_sc_hd__decap_3
XFILLER_35_261 VGND VGND VPWR VPWR sky130_fd_sc_hd__decap_3
XFILLER_51_721 VGND VGND VPWR VPWR sky130_fd_sc_hd__decap_3
XFILLER_23_412 VGND VGND VPWR VPWR sky130_fd_sc_hd__decap_3
XFILLER_51_732 VGND VGND VPWR VPWR sky130_fd_sc_hd__decap_3
X_6825_ _6967_/CLK _6825_/D VGND VGND VPWR VPWR _6825_/Q sky130_fd_sc_hd__dfxtp_2
XFILLER_23_467 VGND VGND VPWR VPWR sky130_fd_sc_hd__decap_3
XFILLER_11_629 VGND VGND VPWR VPWR sky130_fd_sc_hd__decap_3
X_3968_ _7356_/Q _4510_/A0 _3975_/S VGND VGND VPWR VPWR _7356_/D sky130_fd_sc_hd__mux2_2
X_6756_ clkload5/A _6756_/D VGND VGND VPWR VPWR _6756_/Q sky130_fd_sc_hd__dfxtp_2
X_6687_ _7378_/CLK _6687_/D VGND VGND VPWR VPWR _6687_/Q sky130_fd_sc_hd__dfxtp_2
X_3899_ _6693_/Q _3925_/A2 _3925_/B1 _6871_/Q _3746_/C VGND VGND VPWR VPWR _3899_/X
+ sky130_fd_sc_hd__a221o_2
XTAP_TAPCELL_ROW_98_1545 VGND VPWR sky130_fd_sc_hd__tapvpwrvgnd_1
XFILLER_109_528 VGND VGND VPWR VPWR sky130_fd_sc_hd__decap_3
XFILLER_117_550 VGND VGND VPWR VPWR sky130_fd_sc_hd__decap_3
X_5569_ hold947/X _4909_/A _4910_/B VGND VGND VPWR VPWR _7048_/D sky130_fd_sc_hd__a21bo_2
XFILLER_117_561 VGND VGND VPWR VPWR sky130_fd_sc_hd__decap_3
XFILLER_105_712 VGND VGND VPWR VPWR sky130_fd_sc_hd__decap_3
X_7308_ _7372_/CLK _7308_/D _6588_/Y VGND VGND VPWR VPWR _7308_/Q sky130_fd_sc_hd__dfrtp_2
XFILLER_117_594 VGND VGND VPWR VPWR sky130_fd_sc_hd__decap_3
XFILLER_78_607 VGND VGND VPWR VPWR sky130_fd_sc_hd__decap_3
XFILLER_120_704 VGND VGND VPWR VPWR sky130_fd_sc_hd__decap_3
X_7239_ _7372_/CLK _7239_/D _6519_/Y VGND VGND VPWR VPWR _7239_/Q sky130_fd_sc_hd__dfrtp_2
XFILLER_104_266 VGND VGND VPWR VPWR sky130_fd_sc_hd__decap_3
XFILLER_77_128 VGND VGND VPWR VPWR sky130_fd_sc_hd__decap_3
XFILLER_86_640 VGND VGND VPWR VPWR sky130_fd_sc_hd__decap_3
XFILLER_58_331 VGND VGND VPWR VPWR sky130_fd_sc_hd__decap_3
XFILLER_86_651 VGND VGND VPWR VPWR sky130_fd_sc_hd__decap_3
XFILLER_46_504 VGND VGND VPWR VPWR sky130_fd_sc_hd__decap_3
XFILLER_19_718 VGND VGND VPWR VPWR sky130_fd_sc_hd__decap_3
XFILLER_19_729 VGND VGND VPWR VPWR sky130_fd_sc_hd__decap_3
XFILLER_86_684 VGND VGND VPWR VPWR sky130_fd_sc_hd__decap_3
XFILLER_85_161 VGND VGND VPWR VPWR sky130_fd_sc_hd__decap_3
XFILLER_85_172 VGND VGND VPWR VPWR sky130_fd_sc_hd__decap_3
XFILLER_100_483 VGND VGND VPWR VPWR sky130_fd_sc_hd__decap_3
XTAP_TAPCELL_ROW_107_1652 VGND VPWR sky130_fd_sc_hd__tapvpwrvgnd_1
XTAP_TAPCELL_ROW_107_1663 VGND VPWR sky130_fd_sc_hd__tapvpwrvgnd_1
XFILLER_42_710 VGND VGND VPWR VPWR sky130_fd_sc_hd__decap_3
XFILLER_54_581 VGND VGND VPWR VPWR sky130_fd_sc_hd__decap_3
XFILLER_53_31 VGND VGND VPWR VPWR sky130_fd_sc_hd__fill_2
XFILLER_26_283 VGND VGND VPWR VPWR sky130_fd_sc_hd__fill_1
XFILLER_41_231 VGND VGND VPWR VPWR sky130_fd_sc_hd__decap_3
XTAP_TAPCELL_ROW_120_1830 VGND VPWR sky130_fd_sc_hd__tapvpwrvgnd_1
XFILLER_53_53 VGND VGND VPWR VPWR sky130_fd_sc_hd__decap_3
XFILLER_53_97 VGND VGND VPWR VPWR sky130_fd_sc_hd__decap_3
XFILLER_41_275 VGND VGND VPWR VPWR sky130_fd_sc_hd__decap_3
XFILLER_10_640 VGND VGND VPWR VPWR sky130_fd_sc_hd__decap_3
XFILLER_10_651 VGND VGND VPWR VPWR sky130_fd_sc_hd__decap_3
XFILLER_6_622 VGND VGND VPWR VPWR sky130_fd_sc_hd__decap_3
XFILLER_10_684 VGND VGND VPWR VPWR sky130_fd_sc_hd__decap_3
XTAP_TAPCELL_ROW_58_1017 VGND VPWR sky130_fd_sc_hd__tapvpwrvgnd_1
XFILLER_6_666 VGND VGND VPWR VPWR sky130_fd_sc_hd__decap_3
XFILLER_108_572 VGND VGND VPWR VPWR sky130_fd_sc_hd__decap_3
XFILLER_6_699 VGND VGND VPWR VPWR sky130_fd_sc_hd__fill_1
XFILLER_123_542 VGND VGND VPWR VPWR sky130_fd_sc_hd__decap_3
XFILLER_123_564 VGND VGND VPWR VPWR sky130_fd_sc_hd__decap_3
XFILLER_69_629 VGND VGND VPWR VPWR sky130_fd_sc_hd__decap_3
XFILLER_111_715 VGND VGND VPWR VPWR sky130_fd_sc_hd__decap_3
XFILLER_96_415 VGND VGND VPWR VPWR sky130_fd_sc_hd__decap_3
XFILLER_78_72 VGND VGND VPWR VPWR sky130_fd_sc_hd__decap_3
XFILLER_110_203 VGND VGND VPWR VPWR sky130_fd_sc_hd__decap_3
XFILLER_78_94 VGND VGND VPWR VPWR sky130_fd_sc_hd__decap_3
XFILLER_49_320 VGND VGND VPWR VPWR sky130_fd_sc_hd__fill_2
XFILLER_1_382 VGND VGND VPWR VPWR sky130_fd_sc_hd__fill_1
XFILLER_1_393 VGND VGND VPWR VPWR sky130_fd_sc_hd__fill_1
XFILLER_77_662 VGND VGND VPWR VPWR sky130_fd_sc_hd__decap_3
XFILLER_49_353 VGND VGND VPWR VPWR sky130_fd_sc_hd__decap_3
XFILLER_83_109 VGND VGND VPWR VPWR sky130_fd_sc_hd__decap_3
XFILLER_77_673 VGND VGND VPWR VPWR sky130_fd_sc_hd__decap_3
XFILLER_92_610 VGND VGND VPWR VPWR sky130_fd_sc_hd__decap_3
XFILLER_49_375 VGND VGND VPWR VPWR sky130_fd_sc_hd__decap_3
XFILLER_37_537 VGND VGND VPWR VPWR sky130_fd_sc_hd__decap_3
XFILLER_92_643 VGND VGND VPWR VPWR sky130_fd_sc_hd__fill_1
XFILLER_92_654 VGND VGND VPWR VPWR sky130_fd_sc_hd__decap_3
XFILLER_91_131 VGND VGND VPWR VPWR sky130_fd_sc_hd__decap_3
XFILLER_64_345 VGND VGND VPWR VPWR sky130_fd_sc_hd__decap_3
XTAP_TAPCELL_ROW_69_1168 VGND VPWR sky130_fd_sc_hd__tapvpwrvgnd_1
XTAP_TAPCELL_ROW_35_716 VGND VPWR sky130_fd_sc_hd__tapvpwrvgnd_1
X_4940_ _4814_/A _4937_/Y _4939_/X VGND VGND VPWR VPWR _4940_/Y sky130_fd_sc_hd__o21ai_2
XFILLER_92_687 VGND VGND VPWR VPWR sky130_fd_sc_hd__decap_3
XFILLER_64_378 VGND VGND VPWR VPWR sky130_fd_sc_hd__fill_2
XFILLER_91_175 VGND VGND VPWR VPWR sky130_fd_sc_hd__decap_3
XFILLER_45_570 VGND VGND VPWR VPWR sky130_fd_sc_hd__fill_1
XTAP_TAPCELL_ROW_35_727 VGND VPWR sky130_fd_sc_hd__tapvpwrvgnd_1
XFILLER_33_721 VGND VGND VPWR VPWR sky130_fd_sc_hd__decap_3
XFILLER_45_592 VGND VGND VPWR VPWR sky130_fd_sc_hd__decap_3
XFILLER_33_732 VGND VGND VPWR VPWR sky130_fd_sc_hd__decap_3
XTAP_TAPCELL_ROW_82_1335 VGND VPWR sky130_fd_sc_hd__tapvpwrvgnd_1
X_4871_ _4845_/A _4643_/Y _4841_/Y _4829_/A VGND VGND VPWR VPWR _4871_/Y sky130_fd_sc_hd__a31oi_2
XFILLER_32_231 VGND VGND VPWR VPWR sky130_fd_sc_hd__decap_3
XFILLER_32_253 VGND VGND VPWR VPWR sky130_fd_sc_hd__fill_2
X_3822_ hold959/X _3857_/A2 _5010_/C VGND VGND VPWR VPWR _7389_/D sky130_fd_sc_hd__a21o_2
X_6610_ _6610_/A VGND VGND VPWR VPWR _6610_/Y sky130_fd_sc_hd__inv_2
XTAP_TAPCELL_ROW_15_462 VGND VPWR sky130_fd_sc_hd__tapvpwrvgnd_1
XFILLER_32_297 VGND VGND VPWR VPWR sky130_fd_sc_hd__decap_3
X_6541_ _6542_/A VGND VGND VPWR VPWR _6541_/Y sky130_fd_sc_hd__inv_2
X_3753_ _3682_/A _3752_/X _4791_/A1 VGND VGND VPWR VPWR _3753_/X sky130_fd_sc_hd__a21o_2
X_6472_ _6624_/A VGND VGND VPWR VPWR _6472_/Y sky130_fd_sc_hd__inv_2
X_3684_ hold946/X _3857_/A2 _3683_/Y VGND VGND VPWR VPWR _7404_/D sky130_fd_sc_hd__a21bo_2
XFILLER_118_347 VGND VGND VPWR VPWR sky130_fd_sc_hd__decap_3
XFILLER_118_358 VGND VGND VPWR VPWR sky130_fd_sc_hd__fill_1
X_5423_ _5423_/A0 _5139_/X _5429_/S VGND VGND VPWR VPWR _7122_/D sky130_fd_sc_hd__mux2_2
XFILLER_114_520 VGND VGND VPWR VPWR sky130_fd_sc_hd__decap_3
X_5354_ _5354_/A0 _5139_/X _7412_/A VGND VGND VPWR VPWR _7154_/D sky130_fd_sc_hd__mux2_2
XFILLER_99_231 VGND VGND VPWR VPWR sky130_fd_sc_hd__decap_3
XFILLER_114_542 VGND VGND VPWR VPWR sky130_fd_sc_hd__decap_3
XTAP_TAPCELL_ROW_93_1475 VGND VPWR sky130_fd_sc_hd__tapvpwrvgnd_1
X_4305_ _7064_/Q _4305_/B VGND VGND VPWR VPWR _4364_/B sky130_fd_sc_hd__nor2_2
XFILLER_99_253 VGND VGND VPWR VPWR sky130_fd_sc_hd__decap_3
XFILLER_102_704 VGND VGND VPWR VPWR sky130_fd_sc_hd__decap_3
XFILLER_114_575 VGND VGND VPWR VPWR sky130_fd_sc_hd__decap_3
X_7024_ _7399_/CLK _7024_/D _6304_/Y VGND VGND VPWR VPWR _7024_/Q sky130_fd_sc_hd__dfrtp_2
XFILLER_101_225 VGND VGND VPWR VPWR sky130_fd_sc_hd__decap_3
X_4236_ _7163_/Q _4348_/A2 _4234_/X _4235_/X VGND VGND VPWR VPWR _4236_/X sky130_fd_sc_hd__a211o_2
XFILLER_87_459 VGND VGND VPWR VPWR sky130_fd_sc_hd__decap_3
XFILLER_68_640 VGND VGND VPWR VPWR sky130_fd_sc_hd__decap_3
XFILLER_114_15 VGND VGND VPWR VPWR sky130_fd_sc_hd__decap_3
XFILLER_68_651 VGND VGND VPWR VPWR sky130_fd_sc_hd__decap_3
XFILLER_28_504 VGND VGND VPWR VPWR sky130_fd_sc_hd__decap_3
X_4167_ _7393_/Q _4268_/B1 _4979_/S _7297_/Q _4166_/X VGND VGND VPWR VPWR _4167_/X
+ sky130_fd_sc_hd__a221o_2
XFILLER_68_684 VGND VGND VPWR VPWR sky130_fd_sc_hd__decap_3
XFILLER_95_470 VGND VGND VPWR VPWR sky130_fd_sc_hd__decap_3
XFILLER_114_59 VGND VGND VPWR VPWR sky130_fd_sc_hd__decap_3
XFILLER_67_172 VGND VGND VPWR VPWR sky130_fd_sc_hd__decap_3
XFILLER_83_632 VGND VGND VPWR VPWR sky130_fd_sc_hd__decap_3
XFILLER_67_183 VGND VGND VPWR VPWR sky130_fd_sc_hd__decap_3
X_4098_ _7333_/Q _3956_/S _4419_/B1 _7365_/Q _4429_/C1 VGND VGND VPWR VPWR _4098_/X
+ sky130_fd_sc_hd__a221o_2
XFILLER_83_665 VGND VGND VPWR VPWR sky130_fd_sc_hd__decap_3
XFILLER_82_131 VGND VGND VPWR VPWR sky130_fd_sc_hd__decap_3
XFILLER_83_676 VGND VGND VPWR VPWR sky130_fd_sc_hd__decap_3
XFILLER_70_315 VGND VGND VPWR VPWR sky130_fd_sc_hd__decap_3
XFILLER_43_529 VGND VGND VPWR VPWR sky130_fd_sc_hd__decap_3
XFILLER_24_710 VGND VGND VPWR VPWR sky130_fd_sc_hd__decap_3
XFILLER_82_197 VGND VGND VPWR VPWR sky130_fd_sc_hd__decap_3
XFILLER_36_592 VGND VGND VPWR VPWR sky130_fd_sc_hd__decap_3
XFILLER_70_348 VGND VGND VPWR VPWR sky130_fd_sc_hd__decap_3
XFILLER_90_29 VGND VGND VPWR VPWR sky130_fd_sc_hd__decap_3
X_6808_ _6965_/CLK _6808_/D VGND VGND VPWR VPWR _6808_/Q sky130_fd_sc_hd__dfxtp_2
XFILLER_11_426 VGND VGND VPWR VPWR sky130_fd_sc_hd__decap_3
XTAP_TAPCELL_ROW_102_1593 VGND VPWR sky130_fd_sc_hd__tapvpwrvgnd_1
XFILLER_7_408 VGND VGND VPWR VPWR sky130_fd_sc_hd__decap_3
X_6739_ _6967_/CLK _6739_/D VGND VGND VPWR VPWR _6739_/Q sky130_fd_sc_hd__dfxtp_2
XFILLER_3_603 VGND VGND VPWR VPWR sky130_fd_sc_hd__decap_3
XFILLER_2_113 VGND VGND VPWR VPWR sky130_fd_sc_hd__fill_1
XFILLER_3_647 VGND VGND VPWR VPWR sky130_fd_sc_hd__decap_3
XFILLER_105_564 VGND VGND VPWR VPWR sky130_fd_sc_hd__decap_3
XFILLER_120_501 VGND VGND VPWR VPWR sky130_fd_sc_hd__decap_3
XFILLER_105_597 VGND VGND VPWR VPWR sky130_fd_sc_hd__decap_3
XFILLER_78_459 VGND VGND VPWR VPWR sky130_fd_sc_hd__fill_1
XFILLER_120_545 VGND VGND VPWR VPWR sky130_fd_sc_hd__decap_3
XFILLER_59_662 VGND VGND VPWR VPWR sky130_fd_sc_hd__decap_3
XFILLER_65_109 VGND VGND VPWR VPWR sky130_fd_sc_hd__decap_3
XFILLER_59_673 VGND VGND VPWR VPWR sky130_fd_sc_hd__decap_3
XFILLER_120_578 VGND VGND VPWR VPWR sky130_fd_sc_hd__decap_3
XFILLER_120_589 VGND VGND VPWR VPWR sky130_fd_sc_hd__decap_3
XFILLER_74_610 VGND VGND VPWR VPWR sky130_fd_sc_hd__decap_3
XFILLER_58_161 VGND VGND VPWR VPWR sky130_fd_sc_hd__decap_3
XFILLER_46_301 VGND VGND VPWR VPWR sky130_fd_sc_hd__decap_3
XFILLER_74_643 VGND VGND VPWR VPWR sky130_fd_sc_hd__fill_1
XFILLER_100_280 VGND VGND VPWR VPWR sky130_fd_sc_hd__decap_3
XPHY_EDGE_ROW_100_Left_224 VGND VGND VPWR VPWR sky130_fd_sc_hd__decap_3
XFILLER_58_194 VGND VGND VPWR VPWR sky130_fd_sc_hd__fill_2
XFILLER_19_559 VGND VGND VPWR VPWR sky130_fd_sc_hd__fill_1
XFILLER_74_654 VGND VGND VPWR VPWR sky130_fd_sc_hd__decap_3
XFILLER_74_687 VGND VGND VPWR VPWR sky130_fd_sc_hd__decap_3
XFILLER_46_389 VGND VGND VPWR VPWR sky130_fd_sc_hd__decap_3
XFILLER_34_529 VGND VGND VPWR VPWR sky130_fd_sc_hd__decap_3
XFILLER_73_175 VGND VGND VPWR VPWR sky130_fd_sc_hd__fill_2
XFILLER_64_52 VGND VGND VPWR VPWR sky130_fd_sc_hd__fill_1
XFILLER_27_581 VGND VGND VPWR VPWR sky130_fd_sc_hd__decap_3
XFILLER_15_721 VGND VGND VPWR VPWR sky130_fd_sc_hd__decap_3
XFILLER_73_197 VGND VGND VPWR VPWR sky130_fd_sc_hd__decap_3
XFILLER_61_337 VGND VGND VPWR VPWR sky130_fd_sc_hd__decap_3
XFILLER_15_732 VGND VGND VPWR VPWR sky130_fd_sc_hd__decap_3
XFILLER_64_85 VGND VGND VPWR VPWR sky130_fd_sc_hd__decap_3
XFILLER_9_36 VGND VGND VPWR VPWR sky130_fd_sc_hd__decap_3
XFILLER_30_713 VGND VGND VPWR VPWR sky130_fd_sc_hd__decap_3
XFILLER_42_595 VGND VGND VPWR VPWR sky130_fd_sc_hd__decap_3
XFILLER_120_80 VGND VGND VPWR VPWR sky130_fd_sc_hd__decap_3
XTAP_TAPCELL_ROW_64_1098 VGND VPWR sky130_fd_sc_hd__tapvpwrvgnd_1
XFILLER_120_91 VGND VGND VPWR VPWR sky130_fd_sc_hd__decap_3
XTAP_TAPCELL_ROW_12_421 VGND VPWR sky130_fd_sc_hd__tapvpwrvgnd_1
XFILLER_80_73 VGND VGND VPWR VPWR sky130_fd_sc_hd__decap_3
XTAP_TAPCELL_ROW_40_785 VGND VPWR sky130_fd_sc_hd__tapvpwrvgnd_1
XFILLER_10_470 VGND VGND VPWR VPWR sky130_fd_sc_hd__decap_3
XFILLER_6_441 VGND VGND VPWR VPWR sky130_fd_sc_hd__decap_3
Xhold909 _6708_/Q VGND VGND VPWR VPWR hold909/X sky130_fd_sc_hd__dlygate4sd3_1
XFILLER_6_463 VGND VGND VPWR VPWR sky130_fd_sc_hd__decap_3
XFILLER_115_317 VGND VGND VPWR VPWR sky130_fd_sc_hd__decap_3
XFILLER_89_82 VGND VGND VPWR VPWR sky130_fd_sc_hd__decap_3
XFILLER_97_724 VGND VGND VPWR VPWR sky130_fd_sc_hd__decap_3
XFILLER_111_534 VGND VGND VPWR VPWR sky130_fd_sc_hd__decap_3
X_5070_ _5073_/A _5050_/X _5053_/Y VGND VGND VPWR VPWR _5075_/A sky130_fd_sc_hd__o21a_2
XFILLER_111_567 VGND VGND VPWR VPWR sky130_fd_sc_hd__decap_3
XFILLER_84_418 VGND VGND VPWR VPWR sky130_fd_sc_hd__fill_2
XFILLER_77_470 VGND VGND VPWR VPWR sky130_fd_sc_hd__decap_3
XFILLER_65_610 VGND VGND VPWR VPWR sky130_fd_sc_hd__decap_3
XFILLER_49_172 VGND VGND VPWR VPWR sky130_fd_sc_hd__decap_3
XFILLER_65_632 VGND VGND VPWR VPWR sky130_fd_sc_hd__decap_3
XFILLER_37_334 VGND VGND VPWR VPWR sky130_fd_sc_hd__fill_2
XFILLER_65_665 VGND VGND VPWR VPWR sky130_fd_sc_hd__decap_3
XFILLER_65_676 VGND VGND VPWR VPWR sky130_fd_sc_hd__decap_3
XFILLER_92_462 VGND VGND VPWR VPWR sky130_fd_sc_hd__decap_3
XFILLER_80_613 VGND VGND VPWR VPWR sky130_fd_sc_hd__decap_3
XFILLER_52_304 VGND VGND VPWR VPWR sky130_fd_sc_hd__decap_3
XTAP_TAPCELL_ROW_48_885 VGND VPWR sky130_fd_sc_hd__tapvpwrvgnd_1
XTAP_TAPCELL_ROW_48_896 VGND VPWR sky130_fd_sc_hd__tapvpwrvgnd_1
XFILLER_52_326 VGND VGND VPWR VPWR sky130_fd_sc_hd__decap_3
XFILLER_18_581 VGND VGND VPWR VPWR sky130_fd_sc_hd__decap_3
XFILLER_64_197 VGND VGND VPWR VPWR sky130_fd_sc_hd__decap_3
XFILLER_18_592 VGND VGND VPWR VPWR sky130_fd_sc_hd__decap_3
XFILLER_80_657 VGND VGND VPWR VPWR sky130_fd_sc_hd__decap_3
X_4923_ _4920_/A _4922_/X _4969_/B VGND VGND VPWR VPWR _4923_/Y sky130_fd_sc_hd__o21ai_2
XFILLER_33_551 VGND VGND VPWR VPWR sky130_fd_sc_hd__fill_1
XFILLER_33_584 VGND VGND VPWR VPWR sky130_fd_sc_hd__decap_3
XFILLER_21_724 VGND VGND VPWR VPWR sky130_fd_sc_hd__decap_3
X_4854_ _4764_/B _4096_/A _4633_/A _5101_/A VGND VGND VPWR VPWR _4854_/X sky130_fd_sc_hd__o22a_2
X_3805_ _6948_/Q _3884_/B1 _3883_/B1 _6960_/Q VGND VGND VPWR VPWR _3805_/X sky130_fd_sc_hd__a22o_2
X_4785_ _4785_/A _4811_/B VGND VGND VPWR VPWR _4795_/B sky130_fd_sc_hd__nand2_2
XFILLER_119_612 VGND VGND VPWR VPWR sky130_fd_sc_hd__decap_3
XFILLER_20_256 VGND VGND VPWR VPWR sky130_fd_sc_hd__decap_3
XFILLER_119_623 VGND VGND VPWR VPWR sky130_fd_sc_hd__decap_3
XFILLER_118_100 VGND VGND VPWR VPWR sky130_fd_sc_hd__decap_3
X_6524_ _6619_/A VGND VGND VPWR VPWR _6524_/Y sky130_fd_sc_hd__inv_2
XFILLER_20_289 VGND VGND VPWR VPWR sky130_fd_sc_hd__fill_2
XTAP_TAPCELL_ROW_95_1504 VGND VPWR sky130_fd_sc_hd__tapvpwrvgnd_1
XFILLER_119_656 VGND VGND VPWR VPWR sky130_fd_sc_hd__decap_3
XFILLER_9_290 VGND VGND VPWR VPWR sky130_fd_sc_hd__decap_3
XFILLER_118_133 VGND VGND VPWR VPWR sky130_fd_sc_hd__decap_3
XFILLER_109_15 VGND VGND VPWR VPWR sky130_fd_sc_hd__decap_3
X_6455_ _6651_/A VGND VGND VPWR VPWR _6455_/Y sky130_fd_sc_hd__inv_2
XFILLER_109_48 VGND VGND VPWR VPWR sky130_fd_sc_hd__decap_3
X_6386_ _6387_/A VGND VGND VPWR VPWR _6386_/Y sky130_fd_sc_hd__inv_2
X_3598_ _3598_/A _3611_/B VGND VGND VPWR VPWR _4614_/B sky130_fd_sc_hd__nor2_2
XFILLER_88_713 VGND VGND VPWR VPWR sky130_fd_sc_hd__decap_3
XFILLER_0_617 VGND VGND VPWR VPWR sky130_fd_sc_hd__decap_3
XFILLER_87_223 VGND VGND VPWR VPWR sky130_fd_sc_hd__fill_1
XFILLER_102_545 VGND VGND VPWR VPWR sky130_fd_sc_hd__decap_3
X_5268_ _5268_/A0 _5027_/X _5278_/S VGND VGND VPWR VPWR _7196_/D sky130_fd_sc_hd__mux2_2
XFILLER_87_245 VGND VGND VPWR VPWR sky130_fd_sc_hd__decap_3
XFILLER_102_578 VGND VGND VPWR VPWR sky130_fd_sc_hd__decap_3
X_4219_ _7292_/Q _5028_/S _4267_/B1 _7164_/Q _4218_/X VGND VGND VPWR VPWR _4219_/X
+ sky130_fd_sc_hd__a221o_2
X_7007_ _7406_/CLK _7007_/D _6287_/Y VGND VGND VPWR VPWR _7007_/Q sky130_fd_sc_hd__dfrtp_2
XFILLER_87_278 VGND VGND VPWR VPWR sky130_fd_sc_hd__fill_2
XFILLER_102_589 VGND VGND VPWR VPWR sky130_fd_sc_hd__decap_3
XFILLER_56_610 VGND VGND VPWR VPWR sky130_fd_sc_hd__decap_3
XFILLER_28_301 VGND VGND VPWR VPWR sky130_fd_sc_hd__decap_3
XFILLER_28_312 VGND VGND VPWR VPWR sky130_fd_sc_hd__decap_3
XFILLER_68_492 VGND VGND VPWR VPWR sky130_fd_sc_hd__decap_3
XFILLER_56_643 VGND VGND VPWR VPWR sky130_fd_sc_hd__fill_1
XFILLER_56_654 VGND VGND VPWR VPWR sky130_fd_sc_hd__decap_3
XFILLER_28_345 VGND VGND VPWR VPWR sky130_fd_sc_hd__decap_3
XFILLER_55_142 VGND VGND VPWR VPWR sky130_fd_sc_hd__decap_3
XFILLER_83_473 VGND VGND VPWR VPWR sky130_fd_sc_hd__decap_3
XFILLER_71_613 VGND VGND VPWR VPWR sky130_fd_sc_hd__decap_3
XFILLER_56_687 VGND VGND VPWR VPWR sky130_fd_sc_hd__decap_3
XFILLER_71_635 VGND VGND VPWR VPWR sky130_fd_sc_hd__decap_3
XTAP_TAPCELL_ROW_104_1622 VGND VPWR sky130_fd_sc_hd__tapvpwrvgnd_1
XFILLER_55_197 VGND VGND VPWR VPWR sky130_fd_sc_hd__decap_3
XFILLER_43_337 VGND VGND VPWR VPWR sky130_fd_sc_hd__decap_3
XFILLER_34_11 VGND VGND VPWR VPWR sky130_fd_sc_hd__fill_1
XFILLER_71_668 VGND VGND VPWR VPWR sky130_fd_sc_hd__decap_3
XFILLER_71_679 VGND VGND VPWR VPWR sky130_fd_sc_hd__decap_3
XFILLER_70_156 VGND VGND VPWR VPWR sky130_fd_sc_hd__decap_3
XFILLER_12_713 VGND VGND VPWR VPWR sky130_fd_sc_hd__decap_3
XFILLER_24_584 VGND VGND VPWR VPWR sky130_fd_sc_hd__decap_3
XFILLER_24_595 VGND VGND VPWR VPWR sky130_fd_sc_hd__decap_3
XFILLER_8_728 VGND VGND VPWR VPWR sky130_fd_sc_hd__decap_3
XFILLER_109_100 VGND VGND VPWR VPWR sky130_fd_sc_hd__decap_3
XFILLER_7_238 VGND VGND VPWR VPWR sky130_fd_sc_hd__decap_3
XFILLER_109_144 VGND VGND VPWR VPWR sky130_fd_sc_hd__decap_3
XFILLER_50_65 VGND VGND VPWR VPWR sky130_fd_sc_hd__decap_3
XFILLER_3_422 VGND VGND VPWR VPWR sky130_fd_sc_hd__decap_3
XTAP_TAPCELL_ROW_115_1762 VGND VPWR sky130_fd_sc_hd__tapvpwrvgnd_1
XFILLER_112_309 VGND VGND VPWR VPWR sky130_fd_sc_hd__decap_3
XFILLER_79_724 VGND VGND VPWR VPWR sky130_fd_sc_hd__decap_3
XFILLER_105_361 VGND VGND VPWR VPWR sky130_fd_sc_hd__decap_3
XFILLER_78_212 VGND VGND VPWR VPWR sky130_fd_sc_hd__decap_3
XFILLER_120_320 VGND VGND VPWR VPWR sky130_fd_sc_hd__decap_3
XFILLER_78_245 VGND VGND VPWR VPWR sky130_fd_sc_hd__decap_3
XFILLER_59_85 VGND VGND VPWR VPWR sky130_fd_sc_hd__decap_3
XFILLER_94_716 VGND VGND VPWR VPWR sky130_fd_sc_hd__decap_3
XFILLER_78_267 VGND VGND VPWR VPWR sky130_fd_sc_hd__fill_2
XFILLER_120_353 VGND VGND VPWR VPWR sky130_fd_sc_hd__decap_3
XFILLER_78_278 VGND VGND VPWR VPWR sky130_fd_sc_hd__decap_3
XFILLER_93_215 VGND VGND VPWR VPWR sky130_fd_sc_hd__decap_3
XFILLER_59_470 VGND VGND VPWR VPWR sky130_fd_sc_hd__decap_3
XFILLER_47_610 VGND VGND VPWR VPWR sky130_fd_sc_hd__decap_3
XFILLER_19_301 VGND VGND VPWR VPWR sky130_fd_sc_hd__fill_2
XFILLER_120_386 VGND VGND VPWR VPWR sky130_fd_sc_hd__decap_3
XFILLER_93_237 VGND VGND VPWR VPWR sky130_fd_sc_hd__decap_3
XFILLER_47_632 VGND VGND VPWR VPWR sky130_fd_sc_hd__decap_3
XFILLER_47_665 VGND VGND VPWR VPWR sky130_fd_sc_hd__decap_3
XFILLER_62_602 VGND VGND VPWR VPWR sky130_fd_sc_hd__decap_3
XFILLER_47_676 VGND VGND VPWR VPWR sky130_fd_sc_hd__decap_3
XFILLER_46_153 VGND VGND VPWR VPWR sky130_fd_sc_hd__decap_3
XTAP_TAPCELL_ROW_66_1127 VGND VPWR sky130_fd_sc_hd__tapvpwrvgnd_1
XFILLER_34_315 VGND VGND VPWR VPWR sky130_fd_sc_hd__fill_2
XFILLER_62_635 VGND VGND VPWR VPWR sky130_fd_sc_hd__decap_3
XFILLER_34_337 VGND VGND VPWR VPWR sky130_fd_sc_hd__decap_3
XFILLER_62_657 VGND VGND VPWR VPWR sky130_fd_sc_hd__decap_3
XTAP_TAPCELL_ROW_45_855 VGND VPWR sky130_fd_sc_hd__tapvpwrvgnd_1
XFILLER_15_573 VGND VGND VPWR VPWR sky130_fd_sc_hd__decap_3
XFILLER_98_6 VGND VGND VPWR VPWR sky130_fd_sc_hd__fill_1
XFILLER_70_690 VGND VGND VPWR VPWR sky130_fd_sc_hd__decap_3
XTAP_TAPCELL_ROW_25_590 VGND VPWR sky130_fd_sc_hd__tapvpwrvgnd_1
XFILLER_30_565 VGND VGND VPWR VPWR sky130_fd_sc_hd__fill_1
XFILLER_30_587 VGND VGND VPWR VPWR sky130_fd_sc_hd__fill_1
XFILLER_30_598 VGND VGND VPWR VPWR sky130_fd_sc_hd__decap_3
X_3521_ _3525_/A _3525_/B VGND VGND VPWR VPWR _3521_/Y sky130_fd_sc_hd__nand2_2
XFILLER_116_604 VGND VGND VPWR VPWR sky130_fd_sc_hd__decap_3
Xhold706 _6976_/Q VGND VGND VPWR VPWR _6976_/D sky130_fd_sc_hd__dlygate4sd3_1
Xhold717 _6860_/Q VGND VGND VPWR VPWR _6860_/D sky130_fd_sc_hd__dlygate4sd3_1
XFILLER_116_637 VGND VGND VPWR VPWR sky130_fd_sc_hd__decap_3
Xhold728 _6848_/Q VGND VGND VPWR VPWR _6848_/D sky130_fd_sc_hd__dlygate4sd3_1
XFILLER_116_648 VGND VGND VPWR VPWR sky130_fd_sc_hd__decap_3
XTAP_TAPCELL_ROW_77_1267 VGND VPWR sky130_fd_sc_hd__tapvpwrvgnd_1
Xhold739 _6967_/Q VGND VGND VPWR VPWR _6967_/D sky130_fd_sc_hd__dlygate4sd3_1
XFILLER_115_169 VGND VGND VPWR VPWR sky130_fd_sc_hd__decap_3
XTAP_TAPCELL_ROW_90_1434 VGND VPWR sky130_fd_sc_hd__tapvpwrvgnd_1
X_3383_ _5118_/D _3383_/B VGND VGND VPWR VPWR _3562_/A sky130_fd_sc_hd__nor2_2
X_5122_ _5122_/A0 _5121_/X _5157_/S VGND VGND VPWR VPWR _7254_/D sky130_fd_sc_hd__mux2_2
XFILLER_111_320 VGND VGND VPWR VPWR sky130_fd_sc_hd__decap_3
XFILLER_97_576 VGND VGND VPWR VPWR sky130_fd_sc_hd__decap_3
XFILLER_69_267 VGND VGND VPWR VPWR sky130_fd_sc_hd__fill_1
XFILLER_85_727 VGND VGND VPWR VPWR sky130_fd_sc_hd__fill_1
XFILLER_69_278 VGND VGND VPWR VPWR sky130_fd_sc_hd__fill_2
XFILLER_29_109 VGND VGND VPWR VPWR sky130_fd_sc_hd__decap_3
X_5053_ _5073_/A _5050_/X _5020_/A VGND VGND VPWR VPWR _5053_/Y sky130_fd_sc_hd__a21oi_2
XFILLER_84_204 VGND VGND VPWR VPWR sky130_fd_sc_hd__decap_3
XFILLER_57_429 VGND VGND VPWR VPWR sky130_fd_sc_hd__fill_1
XFILLER_38_610 VGND VGND VPWR VPWR sky130_fd_sc_hd__decap_3
XFILLER_84_226 VGND VGND VPWR VPWR sky130_fd_sc_hd__decap_3
XFILLER_38_643 VGND VGND VPWR VPWR sky130_fd_sc_hd__fill_1
XFILLER_65_440 VGND VGND VPWR VPWR sky130_fd_sc_hd__decap_3
XFILLER_38_654 VGND VGND VPWR VPWR sky130_fd_sc_hd__decap_3
XFILLER_38_687 VGND VGND VPWR VPWR sky130_fd_sc_hd__decap_3
XFILLER_65_473 VGND VGND VPWR VPWR sky130_fd_sc_hd__decap_3
XFILLER_53_635 VGND VGND VPWR VPWR sky130_fd_sc_hd__decap_3
XFILLER_37_197 VGND VGND VPWR VPWR sky130_fd_sc_hd__decap_3
XFILLER_25_337 VGND VGND VPWR VPWR sky130_fd_sc_hd__fill_1
XFILLER_92_292 VGND VGND VPWR VPWR sky130_fd_sc_hd__fill_1
XFILLER_80_432 VGND VGND VPWR VPWR sky130_fd_sc_hd__decap_3
XFILLER_111_27 VGND VGND VPWR VPWR sky130_fd_sc_hd__decap_3
XFILLER_53_668 VGND VGND VPWR VPWR sky130_fd_sc_hd__decap_3
XFILLER_25_359 VGND VGND VPWR VPWR sky130_fd_sc_hd__decap_3
XFILLER_53_679 VGND VGND VPWR VPWR sky130_fd_sc_hd__decap_3
X_4906_ _4814_/A _4886_/C _4904_/X _4905_/X VGND VGND VPWR VPWR _4906_/X sky130_fd_sc_hd__o31a_2
X_4837_ hold998/X _4836_/X _4837_/S VGND VGND VPWR VPWR _7271_/D sky130_fd_sc_hd__mux2_2
XFILLER_21_598 VGND VGND VPWR VPWR sky130_fd_sc_hd__decap_3
X_4768_ _4762_/Y _4763_/X _4767_/X VGND VGND VPWR VPWR _4768_/Y sky130_fd_sc_hd__o21ai_2
XFILLER_5_709 VGND VGND VPWR VPWR sky130_fd_sc_hd__decap_3
X_6507_ _6568_/A VGND VGND VPWR VPWR _6507_/Y sky130_fd_sc_hd__inv_2
XFILLER_119_475 VGND VGND VPWR VPWR sky130_fd_sc_hd__decap_3
XFILLER_107_615 VGND VGND VPWR VPWR sky130_fd_sc_hd__fill_1
XFILLER_107_626 VGND VGND VPWR VPWR sky130_fd_sc_hd__decap_3
X_4699_ _6986_/Q _6987_/Q _5098_/A VGND VGND VPWR VPWR _5066_/A sky130_fd_sc_hd__and3_2
XFILLER_106_125 VGND VGND VPWR VPWR sky130_fd_sc_hd__decap_3
XFILLER_107_659 VGND VGND VPWR VPWR sky130_fd_sc_hd__decap_3
X_6438_ _6632_/A VGND VGND VPWR VPWR _6438_/Y sky130_fd_sc_hd__inv_2
XFILLER_122_607 VGND VGND VPWR VPWR sky130_fd_sc_hd__decap_3
XFILLER_106_158 VGND VGND VPWR VPWR sky130_fd_sc_hd__decap_3
X_6369_ _6370_/A VGND VGND VPWR VPWR _6369_/Y sky130_fd_sc_hd__inv_2
XFILLER_88_565 VGND VGND VPWR VPWR sky130_fd_sc_hd__decap_3
XFILLER_76_716 VGND VGND VPWR VPWR sky130_fd_sc_hd__decap_3
XFILLER_88_598 VGND VGND VPWR VPWR sky130_fd_sc_hd__decap_3
XFILLER_29_610 VGND VGND VPWR VPWR sky130_fd_sc_hd__decap_3
XFILLER_102_386 VGND VGND VPWR VPWR sky130_fd_sc_hd__decap_3
XTAP_TAPCELL_ROW_110_1692 VGND VPWR sky130_fd_sc_hd__tapvpwrvgnd_1
XFILLER_29_88 VGND VGND VPWR VPWR sky130_fd_sc_hd__decap_3
XFILLER_29_632 VGND VGND VPWR VPWR sky130_fd_sc_hd__decap_3
XFILLER_75_248 VGND VGND VPWR VPWR sky130_fd_sc_hd__decap_3
XFILLER_29_665 VGND VGND VPWR VPWR sky130_fd_sc_hd__decap_3
XFILLER_29_676 VGND VGND VPWR VPWR sky130_fd_sc_hd__decap_3
XFILLER_90_229 VGND VGND VPWR VPWR sky130_fd_sc_hd__decap_3
XFILLER_44_624 VGND VGND VPWR VPWR sky130_fd_sc_hd__decap_3
XFILLER_16_315 VGND VGND VPWR VPWR sky130_fd_sc_hd__decap_3
XFILLER_83_270 VGND VGND VPWR VPWR sky130_fd_sc_hd__decap_3
XFILLER_43_101 VGND VGND VPWR VPWR sky130_fd_sc_hd__decap_3
XFILLER_83_281 VGND VGND VPWR VPWR sky130_fd_sc_hd__decap_3
XFILLER_56_495 VGND VGND VPWR VPWR sky130_fd_sc_hd__decap_3
XFILLER_45_54 VGND VGND VPWR VPWR sky130_fd_sc_hd__fill_2
XFILLER_28_197 VGND VGND VPWR VPWR sky130_fd_sc_hd__decap_3
XFILLER_71_443 VGND VGND VPWR VPWR sky130_fd_sc_hd__decap_3
XFILLER_44_657 VGND VGND VPWR VPWR sky130_fd_sc_hd__decap_3
XFILLER_71_465 VGND VGND VPWR VPWR sky130_fd_sc_hd__decap_3
XFILLER_45_87 VGND VGND VPWR VPWR sky130_fd_sc_hd__fill_2
XTAP_TAPCELL_ROW_42_814 VGND VPWR sky130_fd_sc_hd__tapvpwrvgnd_1
XFILLER_43_189 VGND VGND VPWR VPWR sky130_fd_sc_hd__fill_1
XFILLER_31_329 VGND VGND VPWR VPWR sky130_fd_sc_hd__decap_3
XFILLER_52_690 VGND VGND VPWR VPWR sky130_fd_sc_hd__decap_3
XFILLER_12_521 VGND VGND VPWR VPWR sky130_fd_sc_hd__decap_3
XFILLER_101_82 VGND VGND VPWR VPWR sky130_fd_sc_hd__decap_3
XTAP_TAPCELL_ROW_61_1057 VGND VPWR sky130_fd_sc_hd__tapvpwrvgnd_1
XFILLER_12_565 VGND VGND VPWR VPWR sky130_fd_sc_hd__decap_3
XFILLER_8_536 VGND VGND VPWR VPWR sky130_fd_sc_hd__decap_3
XFILLER_12_598 VGND VGND VPWR VPWR sky130_fd_sc_hd__decap_3
XFILLER_8_569 VGND VGND VPWR VPWR sky130_fd_sc_hd__decap_3
XFILLER_6_37 VGND VGND VPWR VPWR sky130_fd_sc_hd__fill_1
XANTENNA_8 _3331_/A VGND VGND VPWR VPWR sky130_fd_sc_hd__diode_2
XFILLER_4_731 VGND VGND VPWR VPWR sky130_fd_sc_hd__decap_3
XFILLER_113_629 VGND VGND VPWR VPWR sky130_fd_sc_hd__decap_3
XFILLER_112_117 VGND VGND VPWR VPWR sky130_fd_sc_hd__decap_3
XFILLER_106_681 VGND VGND VPWR VPWR sky130_fd_sc_hd__decap_3
XFILLER_79_543 VGND VGND VPWR VPWR sky130_fd_sc_hd__decap_3
XFILLER_3_296 VGND VGND VPWR VPWR sky130_fd_sc_hd__fill_2
XFILLER_121_662 VGND VGND VPWR VPWR sky130_fd_sc_hd__decap_3
XTAP_TAPCELL_ROW_72_1197 VGND VPWR sky130_fd_sc_hd__tapvpwrvgnd_1
XFILLER_67_727 VGND VGND VPWR VPWR sky130_fd_sc_hd__fill_1
XFILLER_121_673 VGND VGND VPWR VPWR sky130_fd_sc_hd__decap_3
XFILLER_86_61 VGND VGND VPWR VPWR sky130_fd_sc_hd__decap_3
XFILLER_86_83 VGND VGND VPWR VPWR sky130_fd_sc_hd__fill_1
XFILLER_66_237 VGND VGND VPWR VPWR sky130_fd_sc_hd__decap_3
XFILLER_94_568 VGND VGND VPWR VPWR sky130_fd_sc_hd__decap_3
XFILLER_66_259 VGND VGND VPWR VPWR sky130_fd_sc_hd__decap_3
XFILLER_82_719 VGND VGND VPWR VPWR sky130_fd_sc_hd__decap_3
XFILLER_19_175 VGND VGND VPWR VPWR sky130_fd_sc_hd__decap_3
XFILLER_74_281 VGND VGND VPWR VPWR sky130_fd_sc_hd__decap_3
XFILLER_62_421 VGND VGND VPWR VPWR sky130_fd_sc_hd__decap_3
XFILLER_35_635 VGND VGND VPWR VPWR sky130_fd_sc_hd__decap_3
XFILLER_19_197 VGND VGND VPWR VPWR sky130_fd_sc_hd__decap_3
XFILLER_35_668 VGND VGND VPWR VPWR sky130_fd_sc_hd__decap_3
XFILLER_62_454 VGND VGND VPWR VPWR sky130_fd_sc_hd__decap_3
XFILLER_35_679 VGND VGND VPWR VPWR sky130_fd_sc_hd__decap_3
XFILLER_50_616 VGND VGND VPWR VPWR sky130_fd_sc_hd__decap_3
XFILLER_62_498 VGND VGND VPWR VPWR sky130_fd_sc_hd__decap_3
XFILLER_34_189 VGND VGND VPWR VPWR sky130_fd_sc_hd__decap_3
XFILLER_96_3 VGND VGND VPWR VPWR sky130_fd_sc_hd__decap_3
XFILLER_30_340 VGND VGND VPWR VPWR sky130_fd_sc_hd__decap_3
X_5671_ _5671_/A _5671_/B VGND VGND VPWR VPWR _6983_/D sky130_fd_sc_hd__and2_2
X_4622_ _5072_/B _4621_/X _5071_/B VGND VGND VPWR VPWR _4622_/X sky130_fd_sc_hd__a21bo_2
X_7341_ _7368_/CLK _7341_/D _6621_/Y VGND VGND VPWR VPWR _7341_/Q sky130_fd_sc_hd__dfrtp_2
XFILLER_116_401 VGND VGND VPWR VPWR sky130_fd_sc_hd__decap_3
XFILLER_7_591 VGND VGND VPWR VPWR sky130_fd_sc_hd__decap_3
X_3504_ _3501_/X _3502_/X _3630_/A VGND VGND VPWR VPWR _3505_/B sky130_fd_sc_hd__a21oi_2
X_4484_ _4484_/A0 _7305_/Q _4488_/S VGND VGND VPWR VPWR _7337_/D sky130_fd_sc_hd__mux2_2
X_7272_ _7368_/CLK _7272_/D _6552_/Y VGND VGND VPWR VPWR _7272_/Q sky130_fd_sc_hd__dfrtp_2
XFILLER_104_607 VGND VGND VPWR VPWR sky130_fd_sc_hd__decap_3
XFILLER_103_106 VGND VGND VPWR VPWR sky130_fd_sc_hd__decap_3
XFILLER_103_117 VGND VGND VPWR VPWR sky130_fd_sc_hd__decap_3
XFILLER_106_27 VGND VGND VPWR VPWR sky130_fd_sc_hd__fill_1
XFILLER_103_139 VGND VGND VPWR VPWR sky130_fd_sc_hd__fill_2
XFILLER_112_640 VGND VGND VPWR VPWR sky130_fd_sc_hd__decap_3
X_3366_ _3376_/A _3376_/B _3399_/B _5118_/A VGND VGND VPWR VPWR _3366_/X sky130_fd_sc_hd__o211a_2
XFILLER_97_340 VGND VGND VPWR VPWR sky130_fd_sc_hd__decap_3
XFILLER_112_651 VGND VGND VPWR VPWR sky130_fd_sc_hd__decap_3
XFILLER_58_716 VGND VGND VPWR VPWR sky130_fd_sc_hd__decap_3
X_5105_ _4467_/B _3874_/X _5104_/Y _5666_/A VGND VGND VPWR VPWR _5105_/X sky130_fd_sc_hd__a31o_2
Xhold1203 _7150_/Q VGND VGND VPWR VPWR _5365_/A0 sky130_fd_sc_hd__dlygate4sd3_1
XFILLER_112_684 VGND VGND VPWR VPWR sky130_fd_sc_hd__decap_3
Xhold1214 _7230_/Q VGND VGND VPWR VPWR _5196_/A sky130_fd_sc_hd__dlygate4sd3_1
XFILLER_57_215 VGND VGND VPWR VPWR sky130_fd_sc_hd__decap_3
XFILLER_111_161 VGND VGND VPWR VPWR sky130_fd_sc_hd__decap_3
XFILLER_85_535 VGND VGND VPWR VPWR sky130_fd_sc_hd__decap_3
XFILLER_111_172 VGND VGND VPWR VPWR sky130_fd_sc_hd__decap_3
XFILLER_57_237 VGND VGND VPWR VPWR sky130_fd_sc_hd__fill_2
X_5036_ _5036_/A _4674_/X VGND VGND VPWR VPWR _5038_/A sky130_fd_sc_hd__or2b_2
XFILLER_85_579 VGND VGND VPWR VPWR sky130_fd_sc_hd__decap_3
XFILLER_122_26 VGND VGND VPWR VPWR sky130_fd_sc_hd__fill_2
XFILLER_72_218 VGND VGND VPWR VPWR sky130_fd_sc_hd__decap_3
XFILLER_26_613 VGND VGND VPWR VPWR sky130_fd_sc_hd__decap_3
XFILLER_122_59 VGND VGND VPWR VPWR sky130_fd_sc_hd__decap_3
XFILLER_65_281 VGND VGND VPWR VPWR sky130_fd_sc_hd__decap_3
XFILLER_26_657 VGND VGND VPWR VPWR sky130_fd_sc_hd__decap_3
XTAP_TAPCELL_ROW_0_255 VGND VPWR sky130_fd_sc_hd__tapvpwrvgnd_1
XFILLER_53_443 VGND VGND VPWR VPWR sky130_fd_sc_hd__decap_3
XTAP_TAPCELL_ROW_0_266 VGND VPWR sky130_fd_sc_hd__tapvpwrvgnd_1
XFILLER_80_240 VGND VGND VPWR VPWR sky130_fd_sc_hd__decap_3
X_6987_ _7401_/CLK _6987_/D _6267_/Y VGND VGND VPWR VPWR _6987_/Q sky130_fd_sc_hd__dfrtp_2
XFILLER_53_476 VGND VGND VPWR VPWR sky130_fd_sc_hd__decap_3
XFILLER_80_262 VGND VGND VPWR VPWR sky130_fd_sc_hd__decap_3
XFILLER_25_178 VGND VGND VPWR VPWR sky130_fd_sc_hd__fill_1
XFILLER_41_638 VGND VGND VPWR VPWR sky130_fd_sc_hd__decap_3
XFILLER_80_295 VGND VGND VPWR VPWR sky130_fd_sc_hd__decap_3
XFILLER_34_690 VGND VGND VPWR VPWR sky130_fd_sc_hd__decap_3
XFILLER_21_340 VGND VGND VPWR VPWR sky130_fd_sc_hd__fill_2
XFILLER_21_362 VGND VGND VPWR VPWR sky130_fd_sc_hd__decap_3
XFILLER_5_517 VGND VGND VPWR VPWR sky130_fd_sc_hd__fill_2
XFILLER_5_528 VGND VGND VPWR VPWR sky130_fd_sc_hd__decap_3
XFILLER_107_478 VGND VGND VPWR VPWR sky130_fd_sc_hd__decap_3
XTAP_TAPCELL_ROW_112_1721 VGND VPWR sky130_fd_sc_hd__tapvpwrvgnd_1
XFILLER_0_200 VGND VGND VPWR VPWR sky130_fd_sc_hd__decap_3
XFILLER_1_723 VGND VGND VPWR VPWR sky130_fd_sc_hd__decap_3
XFILLER_122_459 VGND VGND VPWR VPWR sky130_fd_sc_hd__decap_3
XTAP_TAPCELL_ROW_8_366 VGND VPWR sky130_fd_sc_hd__tapvpwrvgnd_1
XTAP_TAPCELL_ROW_8_377 VGND VPWR sky130_fd_sc_hd__tapvpwrvgnd_1
XFILLER_103_662 VGND VGND VPWR VPWR sky130_fd_sc_hd__decap_3
XFILLER_88_362 VGND VGND VPWR VPWR sky130_fd_sc_hd__fill_2
XFILLER_49_727 VGND VGND VPWR VPWR sky130_fd_sc_hd__fill_1
XFILLER_103_673 VGND VGND VPWR VPWR sky130_fd_sc_hd__decap_3
XFILLER_0_277 VGND VGND VPWR VPWR sky130_fd_sc_hd__decap_3
XFILLER_88_395 VGND VGND VPWR VPWR sky130_fd_sc_hd__decap_3
XFILLER_48_226 VGND VGND VPWR VPWR sky130_fd_sc_hd__decap_3
XFILLER_102_172 VGND VGND VPWR VPWR sky130_fd_sc_hd__fill_2
XFILLER_0_299 VGND VGND VPWR VPWR sky130_fd_sc_hd__decap_3
XFILLER_48_248 VGND VGND VPWR VPWR sky130_fd_sc_hd__decap_3
XFILLER_102_194 VGND VGND VPWR VPWR sky130_fd_sc_hd__fill_2
XFILLER_76_579 VGND VGND VPWR VPWR sky130_fd_sc_hd__fill_1
XFILLER_64_719 VGND VGND VPWR VPWR sky130_fd_sc_hd__decap_3
XFILLER_17_635 VGND VGND VPWR VPWR sky130_fd_sc_hd__decap_3
XFILLER_44_421 VGND VGND VPWR VPWR sky130_fd_sc_hd__decap_3
XFILLER_56_292 VGND VGND VPWR VPWR sky130_fd_sc_hd__decap_3
XFILLER_44_454 VGND VGND VPWR VPWR sky130_fd_sc_hd__decap_3
XFILLER_17_668 VGND VGND VPWR VPWR sky130_fd_sc_hd__decap_3
XFILLER_17_679 VGND VGND VPWR VPWR sky130_fd_sc_hd__decap_3
XPHY_EDGE_ROW_113_Right_113 VGND VGND VPWR VPWR sky130_fd_sc_hd__decap_3
XFILLER_71_262 VGND VGND VPWR VPWR sky130_fd_sc_hd__decap_3
XFILLER_32_616 VGND VGND VPWR VPWR sky130_fd_sc_hd__decap_3
XFILLER_16_167 VGND VGND VPWR VPWR sky130_fd_sc_hd__decap_3
XTAP_TAPCELL_ROW_123_1861 VGND VPWR sky130_fd_sc_hd__tapvpwrvgnd_1
XTAP_TAPCELL_ROW_55_983 VGND VPWR sky130_fd_sc_hd__tapvpwrvgnd_1
XTAP_TAPCELL_ROW_123_1872 VGND VPWR sky130_fd_sc_hd__tapvpwrvgnd_1
XFILLER_112_92 VGND VGND VPWR VPWR sky130_fd_sc_hd__decap_3
XTAP_TAPCELL_ROW_123_1883 VGND VPWR sky130_fd_sc_hd__tapvpwrvgnd_1
XFILLER_72_85 VGND VGND VPWR VPWR sky130_fd_sc_hd__fill_2
XFILLER_12_340 VGND VGND VPWR VPWR sky130_fd_sc_hd__decap_3
XFILLER_8_300 VGND VGND VPWR VPWR sky130_fd_sc_hd__fill_2
XFILLER_40_660 VGND VGND VPWR VPWR sky130_fd_sc_hd__decap_3
XFILLER_82_9 VGND VGND VPWR VPWR sky130_fd_sc_hd__decap_3
XFILLER_8_333 VGND VGND VPWR VPWR sky130_fd_sc_hd__decap_3
XFILLER_40_693 VGND VGND VPWR VPWR sky130_fd_sc_hd__decap_3
XFILLER_12_395 VGND VGND VPWR VPWR sky130_fd_sc_hd__decap_3
XFILLER_8_388 VGND VGND VPWR VPWR sky130_fd_sc_hd__decap_3
XTAP_TAPCELL_ROW_74_1226 VGND VPWR sky130_fd_sc_hd__tapvpwrvgnd_1
XFILLER_99_638 VGND VGND VPWR VPWR sky130_fd_sc_hd__decap_3
XFILLER_98_115 VGND VGND VPWR VPWR sky130_fd_sc_hd__decap_3
XFILLER_4_572 VGND VGND VPWR VPWR sky130_fd_sc_hd__decap_3
XFILLER_97_82 VGND VGND VPWR VPWR sky130_fd_sc_hd__decap_3
XFILLER_39_215 VGND VGND VPWR VPWR sky130_fd_sc_hd__decap_3
XFILLER_121_470 VGND VGND VPWR VPWR sky130_fd_sc_hd__decap_3
XFILLER_39_237 VGND VGND VPWR VPWR sky130_fd_sc_hd__decap_3
XFILLER_94_365 VGND VGND VPWR VPWR sky130_fd_sc_hd__decap_3
X_6910_ _6960_/CLK _6910_/D VGND VGND VPWR VPWR _6910_/Q sky130_fd_sc_hd__dfxtp_2
XFILLER_54_229 VGND VGND VPWR VPWR sky130_fd_sc_hd__decap_3
XFILLER_47_281 VGND VGND VPWR VPWR sky130_fd_sc_hd__decap_3
XFILLER_35_432 VGND VGND VPWR VPWR sky130_fd_sc_hd__decap_3
X_6841_ clkload4/A _6841_/D VGND VGND VPWR VPWR _6841_/Q sky130_fd_sc_hd__dfxtp_2
XTAP_TAPCELL_ROW_85_1366 VGND VPWR sky130_fd_sc_hd__tapvpwrvgnd_1
XFILLER_90_560 VGND VGND VPWR VPWR sky130_fd_sc_hd__decap_3
XTAP_TAPCELL_ROW_85_1377 VGND VPWR sky130_fd_sc_hd__tapvpwrvgnd_1
XFILLER_62_262 VGND VGND VPWR VPWR sky130_fd_sc_hd__decap_3
XFILLER_23_638 VGND VGND VPWR VPWR sky130_fd_sc_hd__decap_3
XFILLER_50_424 VGND VGND VPWR VPWR sky130_fd_sc_hd__decap_3
XFILLER_35_498 VGND VGND VPWR VPWR sky130_fd_sc_hd__decap_3
X_6772_ _6960_/CLK _6772_/D VGND VGND VPWR VPWR _6772_/Q sky130_fd_sc_hd__dfxtp_2
XFILLER_16_690 VGND VGND VPWR VPWR sky130_fd_sc_hd__decap_3
X_5723_ _7367_/Q hold923/X _5735_/S VGND VGND VPWR VPWR _6711_/D sky130_fd_sc_hd__mux2_2
XFILLER_31_671 VGND VGND VPWR VPWR sky130_fd_sc_hd__fill_1
XTAP_TAPCELL_ROW_33_699 VGND VPWR sky130_fd_sc_hd__tapvpwrvgnd_1
XFILLER_31_682 VGND VGND VPWR VPWR sky130_fd_sc_hd__decap_3
X_5654_ _5665_/A VGND VGND VPWR VPWR _5654_/Y sky130_fd_sc_hd__inv_2
XFILLER_30_181 VGND VGND VPWR VPWR sky130_fd_sc_hd__decap_3
XFILLER_117_721 VGND VGND VPWR VPWR sky130_fd_sc_hd__decap_3
X_5585_ hold931/X _5587_/B _5106_/X VGND VGND VPWR VPWR _7036_/D sky130_fd_sc_hd__a21o_2
XFILLER_117_732 VGND VGND VPWR VPWR sky130_fd_sc_hd__decap_3
X_7324_ _7356_/CLK _7324_/D _6604_/Y VGND VGND VPWR VPWR _7324_/Q sky130_fd_sc_hd__dfrtp_2
X_4536_ hold936/X _3398_/Y _3488_/X VGND VGND VPWR VPWR _7311_/D sky130_fd_sc_hd__a21o_2
XFILLER_116_242 VGND VGND VPWR VPWR sky130_fd_sc_hd__fill_1
XFILLER_117_15 VGND VGND VPWR VPWR sky130_fd_sc_hd__decap_3
XFILLER_104_415 VGND VGND VPWR VPWR sky130_fd_sc_hd__decap_3
X_7255_ _7325_/CLK _7255_/D _6535_/Y VGND VGND VPWR VPWR _7255_/Q sky130_fd_sc_hd__dfrtp_2
XFILLER_117_48 VGND VGND VPWR VPWR sky130_fd_sc_hd__decap_3
XFILLER_116_286 VGND VGND VPWR VPWR sky130_fd_sc_hd__decap_3
X_4467_ _4467_/A _4467_/B VGND VGND VPWR VPWR _4467_/Y sky130_fd_sc_hd__nor2_2
XFILLER_116_297 VGND VGND VPWR VPWR sky130_fd_sc_hd__decap_3
XFILLER_104_448 VGND VGND VPWR VPWR sky130_fd_sc_hd__decap_3
XFILLER_89_159 VGND VGND VPWR VPWR sky130_fd_sc_hd__fill_2
X_3418_ _7283_/Q _5140_/S _3417_/X _7091_/Q VGND VGND VPWR VPWR _3418_/X sky130_fd_sc_hd__a22o_2
X_4398_ _7338_/Q _3943_/S _4486_/S _7306_/Q VGND VGND VPWR VPWR _4398_/X sky130_fd_sc_hd__a22o_2
X_7186_ _7355_/CLK _7186_/D _6466_/Y VGND VGND VPWR VPWR _7186_/Q sky130_fd_sc_hd__dfrtp_2
XFILLER_98_660 VGND VGND VPWR VPWR sky130_fd_sc_hd__decap_3
XTAP_TAPCELL_ROW_5_336 VGND VPWR sky130_fd_sc_hd__tapvpwrvgnd_1
XFILLER_100_610 VGND VGND VPWR VPWR sky130_fd_sc_hd__decap_3
X_3349_ _3386_/A _5294_/A VGND VGND VPWR VPWR _3350_/B sky130_fd_sc_hd__nand2_2
Xhold1000 _6696_/Q VGND VGND VPWR VPWR _5693_/A1 sky130_fd_sc_hd__dlygate4sd3_1
XFILLER_98_693 VGND VGND VPWR VPWR sky130_fd_sc_hd__decap_3
XFILLER_112_470 VGND VGND VPWR VPWR sky130_fd_sc_hd__fill_1
Xhold1011 _7199_/Q VGND VGND VPWR VPWR _5262_/A0 sky130_fd_sc_hd__dlygate4sd3_1
XFILLER_85_332 VGND VGND VPWR VPWR sky130_fd_sc_hd__decap_3
XFILLER_112_492 VGND VGND VPWR VPWR sky130_fd_sc_hd__decap_3
Xhold1022 _7245_/Q VGND VGND VPWR VPWR _5165_/A sky130_fd_sc_hd__dlygate4sd3_1
XFILLER_100_643 VGND VGND VPWR VPWR sky130_fd_sc_hd__fill_1
Xhold1033 _7236_/Q VGND VGND VPWR VPWR _5184_/A sky130_fd_sc_hd__dlygate4sd3_1
XFILLER_100_654 VGND VGND VPWR VPWR sky130_fd_sc_hd__decap_3
Xhold1044 _7020_/Q VGND VGND VPWR VPWR _5615_/A sky130_fd_sc_hd__dlygate4sd3_1
XFILLER_85_354 VGND VGND VPWR VPWR sky130_fd_sc_hd__decap_3
XFILLER_46_719 VGND VGND VPWR VPWR sky130_fd_sc_hd__decap_3
XFILLER_73_505 VGND VGND VPWR VPWR sky130_fd_sc_hd__fill_2
Xhold1055 _7335_/Q VGND VGND VPWR VPWR _4488_/A0 sky130_fd_sc_hd__dlygate4sd3_1
Xhold1066 _7317_/Q VGND VGND VPWR VPWR _4524_/A0 sky130_fd_sc_hd__dlygate4sd3_1
XFILLER_100_687 VGND VGND VPWR VPWR sky130_fd_sc_hd__decap_3
Xhold1077 _7324_/Q VGND VGND VPWR VPWR _4510_/A0 sky130_fd_sc_hd__dlygate4sd3_1
X_5019_ _4243_/Y _5032_/B _4989_/X _5018_/Y VGND VGND VPWR VPWR _5020_/B sky130_fd_sc_hd__a22o_2
Xhold1088 _7256_/Q VGND VGND VPWR VPWR _5095_/A0 sky130_fd_sc_hd__dlygate4sd3_1
Xhold1099 _7134_/Q VGND VGND VPWR VPWR _5398_/A0 sky130_fd_sc_hd__dlygate4sd3_1
XFILLER_73_549 VGND VGND VPWR VPWR sky130_fd_sc_hd__fill_1
XFILLER_26_23 VGND VGND VPWR VPWR sky130_fd_sc_hd__decap_3
XFILLER_38_292 VGND VGND VPWR VPWR sky130_fd_sc_hd__decap_3
XFILLER_53_240 VGND VGND VPWR VPWR sky130_fd_sc_hd__decap_3
XFILLER_26_465 VGND VGND VPWR VPWR sky130_fd_sc_hd__decap_3
XFILLER_14_616 VGND VGND VPWR VPWR sky130_fd_sc_hd__decap_3
XFILLER_53_262 VGND VGND VPWR VPWR sky130_fd_sc_hd__decap_3
XFILLER_81_582 VGND VGND VPWR VPWR sky130_fd_sc_hd__decap_3
XFILLER_53_273 VGND VGND VPWR VPWR sky130_fd_sc_hd__decap_3
XFILLER_53_284 VGND VGND VPWR VPWR sky130_fd_sc_hd__decap_3
XTAP_TAPCELL_ROW_52_942 VGND VPWR sky130_fd_sc_hd__tapvpwrvgnd_1
XFILLER_41_457 VGND VGND VPWR VPWR sky130_fd_sc_hd__decap_3
XFILLER_41_468 VGND VGND VPWR VPWR sky130_fd_sc_hd__decap_3
XFILLER_9_119 VGND VGND VPWR VPWR sky130_fd_sc_hd__decap_3
XFILLER_22_660 VGND VGND VPWR VPWR sky130_fd_sc_hd__decap_3
XFILLER_42_66 VGND VGND VPWR VPWR sky130_fd_sc_hd__decap_3
XFILLER_22_693 VGND VGND VPWR VPWR sky130_fd_sc_hd__decap_3
XFILLER_21_181 VGND VGND VPWR VPWR sky130_fd_sc_hd__decap_3
XFILLER_42_88 VGND VGND VPWR VPWR sky130_fd_sc_hd__decap_3
XFILLER_108_710 VGND VGND VPWR VPWR sky130_fd_sc_hd__decap_3
XFILLER_5_314 VGND VGND VPWR VPWR sky130_fd_sc_hd__fill_2
XFILLER_123_713 VGND VGND VPWR VPWR sky130_fd_sc_hd__decap_3
XFILLER_107_264 VGND VGND VPWR VPWR sky130_fd_sc_hd__decap_3
XFILLER_1_520 VGND VGND VPWR VPWR sky130_fd_sc_hd__decap_3
XFILLER_96_619 VGND VGND VPWR VPWR sky130_fd_sc_hd__decap_3
XFILLER_3_38 VGND VGND VPWR VPWR sky130_fd_sc_hd__fill_2
XFILLER_1_553 VGND VGND VPWR VPWR sky130_fd_sc_hd__decap_3
XFILLER_1_564 VGND VGND VPWR VPWR sky130_fd_sc_hd__decap_3
XFILLER_89_671 VGND VGND VPWR VPWR sky130_fd_sc_hd__fill_1
XFILLER_89_682 VGND VGND VPWR VPWR sky130_fd_sc_hd__decap_3
XFILLER_67_30 VGND VGND VPWR VPWR sky130_fd_sc_hd__decap_3
XFILLER_95_129 VGND VGND VPWR VPWR sky130_fd_sc_hd__decap_3
XFILLER_1_597 VGND VGND VPWR VPWR sky130_fd_sc_hd__decap_3
XFILLER_103_481 VGND VGND VPWR VPWR sky130_fd_sc_hd__decap_3
XFILLER_67_63 VGND VGND VPWR VPWR sky130_fd_sc_hd__decap_3
XFILLER_49_546 VGND VGND VPWR VPWR sky130_fd_sc_hd__fill_2
XFILLER_88_192 VGND VGND VPWR VPWR sky130_fd_sc_hd__decap_3
XFILLER_76_332 VGND VGND VPWR VPWR sky130_fd_sc_hd__fill_2
XFILLER_91_313 VGND VGND VPWR VPWR sky130_fd_sc_hd__fill_1
XFILLER_36_218 VGND VGND VPWR VPWR sky130_fd_sc_hd__decap_3
XFILLER_29_281 VGND VGND VPWR VPWR sky130_fd_sc_hd__decap_3
XFILLER_123_80 VGND VGND VPWR VPWR sky130_fd_sc_hd__decap_3
XFILLER_91_346 VGND VGND VPWR VPWR sky130_fd_sc_hd__decap_3
XFILLER_17_443 VGND VGND VPWR VPWR sky130_fd_sc_hd__fill_2
XFILLER_123_91 VGND VGND VPWR VPWR sky130_fd_sc_hd__fill_2
XFILLER_83_51 VGND VGND VPWR VPWR sky130_fd_sc_hd__decap_3
XFILLER_44_240 VGND VGND VPWR VPWR sky130_fd_sc_hd__decap_3
XFILLER_60_722 VGND VGND VPWR VPWR sky130_fd_sc_hd__decap_3
XFILLER_44_284 VGND VGND VPWR VPWR sky130_fd_sc_hd__decap_3
XFILLER_32_468 VGND VGND VPWR VPWR sky130_fd_sc_hd__decap_3
XFILLER_20_619 VGND VGND VPWR VPWR sky130_fd_sc_hd__decap_3
XFILLER_9_620 VGND VGND VPWR VPWR sky130_fd_sc_hd__decap_3
XFILLER_13_671 VGND VGND VPWR VPWR sky130_fd_sc_hd__fill_1
XFILLER_13_682 VGND VGND VPWR VPWR sky130_fd_sc_hd__decap_3
XFILLER_9_653 VGND VGND VPWR VPWR sky130_fd_sc_hd__decap_3
XFILLER_12_192 VGND VGND VPWR VPWR sky130_fd_sc_hd__decap_3
XFILLER_118_507 VGND VGND VPWR VPWR sky130_fd_sc_hd__decap_3
XTAP_TAPCELL_ROW_30_658 VGND VPWR sky130_fd_sc_hd__tapvpwrvgnd_1
XFILLER_9_697 VGND VGND VPWR VPWR sky130_fd_sc_hd__decap_3
XFILLER_8_185 VGND VGND VPWR VPWR sky130_fd_sc_hd__decap_3
XTAP_TAPCELL_ROW_10_393 VGND VPWR sky130_fd_sc_hd__tapvpwrvgnd_1
XFILLER_59_3 VGND VGND VPWR VPWR sky130_fd_sc_hd__fill_1
XFILLER_114_713 VGND VGND VPWR VPWR sky130_fd_sc_hd__decap_3
X_4321_ _7098_/Q _4335_/B1 _4351_/B1 _7130_/Q VGND VGND VPWR VPWR _4321_/X sky130_fd_sc_hd__a22o_2
XFILLER_99_435 VGND VGND VPWR VPWR sky130_fd_sc_hd__decap_3
XFILLER_113_212 VGND VGND VPWR VPWR sky130_fd_sc_hd__decap_3
XFILLER_113_234 VGND VGND VPWR VPWR sky130_fd_sc_hd__decap_3
X_4252_ _7197_/Q _3966_/S _4108_/B _7357_/Q VGND VGND VPWR VPWR _4252_/X sky130_fd_sc_hd__a22o_2
X_7040_ _7392_/CLK _7040_/D _6320_/Y VGND VGND VPWR VPWR _7040_/Q sky130_fd_sc_hd__dfrtp_2
XFILLER_101_407 VGND VGND VPWR VPWR sky130_fd_sc_hd__decap_3
XFILLER_113_278 VGND VGND VPWR VPWR sky130_fd_sc_hd__fill_2
XFILLER_86_129 VGND VGND VPWR VPWR sky130_fd_sc_hd__decap_3
X_4183_ _7360_/Q _4270_/B _4267_/B1 _7168_/Q _4182_/X VGND VGND VPWR VPWR _4183_/X
+ sky130_fd_sc_hd__a221o_2
XFILLER_67_310 VGND VGND VPWR VPWR sky130_fd_sc_hd__decap_3
XFILLER_95_641 VGND VGND VPWR VPWR sky130_fd_sc_hd__decap_3
XFILLER_67_354 VGND VGND VPWR VPWR sky130_fd_sc_hd__decap_3
XFILLER_55_505 VGND VGND VPWR VPWR sky130_fd_sc_hd__decap_3
XFILLER_28_719 VGND VGND VPWR VPWR sky130_fd_sc_hd__decap_3
XFILLER_95_685 VGND VGND VPWR VPWR sky130_fd_sc_hd__decap_3
XFILLER_82_302 VGND VGND VPWR VPWR sky130_fd_sc_hd__fill_1
XFILLER_67_376 VGND VGND VPWR VPWR sky130_fd_sc_hd__fill_1
XFILLER_55_527 VGND VGND VPWR VPWR sky130_fd_sc_hd__fill_1
XFILLER_27_218 VGND VGND VPWR VPWR sky130_fd_sc_hd__decap_3
XFILLER_55_549 VGND VGND VPWR VPWR sky130_fd_sc_hd__decap_3
XFILLER_82_335 VGND VGND VPWR VPWR sky130_fd_sc_hd__fill_2
XTAP_TAPCELL_ROW_38_758 VGND VPWR sky130_fd_sc_hd__tapvpwrvgnd_1
XFILLER_82_368 VGND VGND VPWR VPWR sky130_fd_sc_hd__decap_3
XFILLER_35_240 VGND VGND VPWR VPWR sky130_fd_sc_hd__decap_3
XFILLER_82_379 VGND VGND VPWR VPWR sky130_fd_sc_hd__decap_3
XFILLER_51_700 VGND VGND VPWR VPWR sky130_fd_sc_hd__decap_3
X_6824_ clkload9/A _6824_/D VGND VGND VPWR VPWR _6824_/Q sky130_fd_sc_hd__dfxtp_2
XFILLER_35_284 VGND VGND VPWR VPWR sky130_fd_sc_hd__decap_3
X_6755_ _6967_/CLK _6755_/D VGND VGND VPWR VPWR _6755_/Q sky130_fd_sc_hd__dfxtp_2
XFILLER_50_265 VGND VGND VPWR VPWR sky130_fd_sc_hd__decap_3
X_5706_ _7359_/Q _5706_/A1 _5708_/S VGND VGND VPWR VPWR _6703_/D sky130_fd_sc_hd__mux2_2
XFILLER_50_298 VGND VGND VPWR VPWR sky130_fd_sc_hd__decap_3
X_6686_ _6686_/A VGND VGND VPWR VPWR _6686_/Y sky130_fd_sc_hd__inv_2
Xclkbuf_leaf_30_clk clkload1/A VGND VGND VPWR VPWR _7356_/CLK sky130_fd_sc_hd__clkbuf_16
XTAP_TAPCELL_ROW_98_1535 VGND VPWR sky130_fd_sc_hd__tapvpwrvgnd_1
X_3898_ _6919_/Q _3898_/A2 _3898_/B1 _6783_/Q VGND VGND VPWR VPWR _3898_/X sky130_fd_sc_hd__a22o_2
XTAP_TAPCELL_ROW_98_1546 VGND VPWR sky130_fd_sc_hd__tapvpwrvgnd_1
X_5568_ hold974/X _4909_/A _4897_/X VGND VGND VPWR VPWR _7049_/D sky130_fd_sc_hd__a21o_2
XFILLER_117_573 VGND VGND VPWR VPWR sky130_fd_sc_hd__decap_3
X_7307_ _7371_/CLK _7307_/D _6587_/Y VGND VGND VPWR VPWR _7307_/Q sky130_fd_sc_hd__dfrtp_2
XFILLER_105_724 VGND VGND VPWR VPWR sky130_fd_sc_hd__decap_3
X_4519_ hold978/X _3398_/Y _4300_/X VGND VGND VPWR VPWR _7320_/D sky130_fd_sc_hd__a21o_2
XFILLER_104_234 VGND VGND VPWR VPWR sky130_fd_sc_hd__decap_3
X_7238_ _7374_/CLK _7238_/D _6518_/Y VGND VGND VPWR VPWR _7238_/Q sky130_fd_sc_hd__dfrtp_2
XFILLER_78_619 VGND VGND VPWR VPWR sky130_fd_sc_hd__decap_3
XFILLER_120_716 VGND VGND VPWR VPWR sky130_fd_sc_hd__decap_3
X_7169_ _7360_/CLK _7169_/D _6449_/Y VGND VGND VPWR VPWR _7169_/Q sky130_fd_sc_hd__dfrtp_2
XFILLER_58_321 VGND VGND VPWR VPWR sky130_fd_sc_hd__decap_3
XFILLER_58_343 VGND VGND VPWR VPWR sky130_fd_sc_hd__decap_3
XFILLER_86_663 VGND VGND VPWR VPWR sky130_fd_sc_hd__decap_3
XFILLER_85_140 VGND VGND VPWR VPWR sky130_fd_sc_hd__decap_3
XFILLER_73_302 VGND VGND VPWR VPWR sky130_fd_sc_hd__decap_3
XFILLER_86_696 VGND VGND VPWR VPWR sky130_fd_sc_hd__decap_3
XFILLER_73_324 VGND VGND VPWR VPWR sky130_fd_sc_hd__decap_3
XFILLER_58_398 VGND VGND VPWR VPWR sky130_fd_sc_hd__decap_3
XFILLER_39_590 VGND VGND VPWR VPWR sky130_fd_sc_hd__decap_3
XFILLER_100_495 VGND VGND VPWR VPWR sky130_fd_sc_hd__decap_3
XFILLER_61_508 VGND VGND VPWR VPWR sky130_fd_sc_hd__decap_3
XTAP_TAPCELL_ROW_107_1653 VGND VPWR sky130_fd_sc_hd__tapvpwrvgnd_1
XTAP_TAPCELL_ROW_107_1664 VGND VPWR sky130_fd_sc_hd__tapvpwrvgnd_1
XFILLER_42_722 VGND VGND VPWR VPWR sky130_fd_sc_hd__decap_3
XFILLER_14_413 VGND VGND VPWR VPWR sky130_fd_sc_hd__decap_3
XFILLER_14_424 VGND VGND VPWR VPWR sky130_fd_sc_hd__decap_3
XFILLER_26_295 VGND VGND VPWR VPWR sky130_fd_sc_hd__decap_3
XTAP_TAPCELL_ROW_120_1831 VGND VPWR sky130_fd_sc_hd__tapvpwrvgnd_1
XFILLER_41_254 VGND VGND VPWR VPWR sky130_fd_sc_hd__decap_3
XFILLER_53_76 VGND VGND VPWR VPWR sky130_fd_sc_hd__fill_1
XFILLER_41_287 VGND VGND VPWR VPWR sky130_fd_sc_hd__decap_3
Xclkbuf_leaf_21_clk clkload3/A VGND VGND VPWR VPWR _7370_/CLK sky130_fd_sc_hd__clkbuf_16
XFILLER_6_601 VGND VGND VPWR VPWR sky130_fd_sc_hd__decap_3
XFILLER_10_663 VGND VGND VPWR VPWR sky130_fd_sc_hd__decap_3
XFILLER_5_100 VGND VGND VPWR VPWR sky130_fd_sc_hd__decap_3
XFILLER_6_634 VGND VGND VPWR VPWR sky130_fd_sc_hd__decap_3
XFILLER_6_645 VGND VGND VPWR VPWR sky130_fd_sc_hd__decap_3
XFILLER_10_696 VGND VGND VPWR VPWR sky130_fd_sc_hd__decap_3
XTAP_TAPCELL_ROW_58_1018 VGND VPWR sky130_fd_sc_hd__tapvpwrvgnd_1
XFILLER_108_551 VGND VGND VPWR VPWR sky130_fd_sc_hd__decap_3
XFILLER_6_678 VGND VGND VPWR VPWR sky130_fd_sc_hd__decap_3
XFILLER_108_584 VGND VGND VPWR VPWR sky130_fd_sc_hd__decap_3
XFILLER_108_595 VGND VGND VPWR VPWR sky130_fd_sc_hd__decap_3
XFILLER_118_80 VGND VGND VPWR VPWR sky130_fd_sc_hd__decap_3
XFILLER_118_91 VGND VGND VPWR VPWR sky130_fd_sc_hd__decap_3
XFILLER_123_587 VGND VGND VPWR VPWR sky130_fd_sc_hd__fill_1
XFILLER_111_727 VGND VGND VPWR VPWR sky130_fd_sc_hd__fill_1
XFILLER_110_215 VGND VGND VPWR VPWR sky130_fd_sc_hd__decap_3
XFILLER_96_438 VGND VGND VPWR VPWR sky130_fd_sc_hd__decap_3
XFILLER_77_641 VGND VGND VPWR VPWR sky130_fd_sc_hd__decap_3
XFILLER_110_248 VGND VGND VPWR VPWR sky130_fd_sc_hd__decap_3
XFILLER_110_259 VGND VGND VPWR VPWR sky130_fd_sc_hd__decap_3
XFILLER_49_365 VGND VGND VPWR VPWR sky130_fd_sc_hd__fill_2
XFILLER_37_505 VGND VGND VPWR VPWR sky130_fd_sc_hd__decap_3
XFILLER_77_685 VGND VGND VPWR VPWR sky130_fd_sc_hd__decap_3
XFILLER_92_622 VGND VGND VPWR VPWR sky130_fd_sc_hd__decap_3
XFILLER_94_61 VGND VGND VPWR VPWR sky130_fd_sc_hd__decap_3
XFILLER_76_195 VGND VGND VPWR VPWR sky130_fd_sc_hd__fill_1
XTAP_TAPCELL_ROW_69_1158 VGND VPWR sky130_fd_sc_hd__tapvpwrvgnd_1
XFILLER_94_94 VGND VGND VPWR VPWR sky130_fd_sc_hd__decap_3
XFILLER_92_666 VGND VGND VPWR VPWR sky130_fd_sc_hd__decap_3
XFILLER_91_143 VGND VGND VPWR VPWR sky130_fd_sc_hd__decap_3
XTAP_TAPCELL_ROW_69_1169 VGND VPWR sky130_fd_sc_hd__tapvpwrvgnd_1
XFILLER_52_519 VGND VGND VPWR VPWR sky130_fd_sc_hd__decap_3
XFILLER_17_240 VGND VGND VPWR VPWR sky130_fd_sc_hd__decap_3
XTAP_TAPCELL_ROW_35_717 VGND VPWR sky130_fd_sc_hd__tapvpwrvgnd_1
XFILLER_92_699 VGND VGND VPWR VPWR sky130_fd_sc_hd__fill_1
XFILLER_33_700 VGND VGND VPWR VPWR sky130_fd_sc_hd__decap_3
XTAP_TAPCELL_ROW_35_728 VGND VPWR sky130_fd_sc_hd__tapvpwrvgnd_1
XFILLER_91_187 VGND VGND VPWR VPWR sky130_fd_sc_hd__fill_2
XFILLER_32_210 VGND VGND VPWR VPWR sky130_fd_sc_hd__decap_3
XTAP_TAPCELL_ROW_82_1336 VGND VPWR sky130_fd_sc_hd__tapvpwrvgnd_1
X_4870_ _4870_/A _4870_/B VGND VGND VPWR VPWR _4870_/Y sky130_fd_sc_hd__nor2_2
XFILLER_72_390 VGND VGND VPWR VPWR sky130_fd_sc_hd__decap_3
XFILLER_32_243 VGND VGND VPWR VPWR sky130_fd_sc_hd__decap_3
X_3821_ _3746_/C _3819_/X _3820_/X _3860_/S VGND VGND VPWR VPWR _5010_/C sky130_fd_sc_hd__o31a_2
XFILLER_60_574 VGND VGND VPWR VPWR sky130_fd_sc_hd__decap_3
XTAP_TAPCELL_ROW_15_463 VGND VPWR sky130_fd_sc_hd__tapvpwrvgnd_1
X_6540_ _6544_/A VGND VGND VPWR VPWR _6540_/Y sky130_fd_sc_hd__inv_2
X_3752_ _6799_/Q _3759_/A2 _3767_/A2 _6709_/Q _3751_/X VGND VGND VPWR VPWR _3752_/X
+ sky130_fd_sc_hd__a221o_2
Xclkbuf_leaf_12_clk clkbuf_leaf_9_clk/A VGND VGND VPWR VPWR _7405_/CLK sky130_fd_sc_hd__clkbuf_16
XFILLER_9_461 VGND VGND VPWR VPWR sky130_fd_sc_hd__decap_3
XFILLER_118_315 VGND VGND VPWR VPWR sky130_fd_sc_hd__fill_2
X_6471_ _6624_/A VGND VGND VPWR VPWR _6471_/Y sky130_fd_sc_hd__inv_2
XFILLER_118_326 VGND VGND VPWR VPWR sky130_fd_sc_hd__decap_3
X_3683_ _3672_/X _3673_/X _4799_/A _3682_/Y VGND VGND VPWR VPWR _3683_/Y sky130_fd_sc_hd__o211ai_2
XFILLER_99_221 VGND VGND VPWR VPWR sky130_fd_sc_hd__decap_3
XTAP_TAPCELL_ROW_93_1476 VGND VPWR sky130_fd_sc_hd__tapvpwrvgnd_1
X_4304_ _7256_/Q _4601_/S _4303_/X VGND VGND VPWR VPWR _4364_/A sky130_fd_sc_hd__a21oi_2
XFILLER_114_554 VGND VGND VPWR VPWR sky130_fd_sc_hd__decap_3
XFILLER_87_405 VGND VGND VPWR VPWR sky130_fd_sc_hd__decap_3
X_5284_ _5284_/A0 _5135_/X _5292_/S VGND VGND VPWR VPWR _7187_/D sky130_fd_sc_hd__mux2_2
XFILLER_99_265 VGND VGND VPWR VPWR sky130_fd_sc_hd__decap_3
XFILLER_102_716 VGND VGND VPWR VPWR sky130_fd_sc_hd__decap_3
XFILLER_114_587 VGND VGND VPWR VPWR sky130_fd_sc_hd__fill_1
XFILLER_99_287 VGND VGND VPWR VPWR sky130_fd_sc_hd__decap_3
X_7023_ _7365_/CLK _7023_/D _6303_/Y VGND VGND VPWR VPWR _7023_/Q sky130_fd_sc_hd__dfrtp_2
XFILLER_114_598 VGND VGND VPWR VPWR sky130_fd_sc_hd__decap_3
X_4235_ _7227_/Q _4349_/B1 _4341_/B1 _7131_/Q VGND VGND VPWR VPWR _4235_/X sky130_fd_sc_hd__a22o_2
XFILLER_87_449 VGND VGND VPWR VPWR sky130_fd_sc_hd__decap_3
XFILLER_101_237 VGND VGND VPWR VPWR sky130_fd_sc_hd__decap_3
XFILLER_68_663 VGND VGND VPWR VPWR sky130_fd_sc_hd__decap_3
XFILLER_114_27 VGND VGND VPWR VPWR sky130_fd_sc_hd__fill_1
X_4166_ _7233_/Q _4414_/A2 _3958_/S _7201_/Q VGND VGND VPWR VPWR _4166_/X sky130_fd_sc_hd__a22o_2
XFILLER_114_38 VGND VGND VPWR VPWR sky130_fd_sc_hd__decap_3
XFILLER_83_600 VGND VGND VPWR VPWR sky130_fd_sc_hd__decap_3
XFILLER_67_151 VGND VGND VPWR VPWR sky130_fd_sc_hd__decap_3
XFILLER_68_696 VGND VGND VPWR VPWR sky130_fd_sc_hd__decap_3
XFILLER_28_527 VGND VGND VPWR VPWR sky130_fd_sc_hd__decap_3
XFILLER_83_644 VGND VGND VPWR VPWR sky130_fd_sc_hd__decap_3
XFILLER_67_195 VGND VGND VPWR VPWR sky130_fd_sc_hd__decap_3
XFILLER_83_688 VGND VGND VPWR VPWR sky130_fd_sc_hd__decap_3
XFILLER_70_305 VGND VGND VPWR VPWR sky130_fd_sc_hd__decap_3
XFILLER_70_327 VGND VGND VPWR VPWR sky130_fd_sc_hd__decap_3
XFILLER_24_722 VGND VGND VPWR VPWR sky130_fd_sc_hd__decap_3
XFILLER_23_210 VGND VGND VPWR VPWR sky130_fd_sc_hd__fill_2
XFILLER_51_530 VGND VGND VPWR VPWR sky130_fd_sc_hd__decap_3
XFILLER_23_221 VGND VGND VPWR VPWR sky130_fd_sc_hd__decap_3
XFILLER_23_232 VGND VGND VPWR VPWR sky130_fd_sc_hd__decap_3
X_6807_ _7403_/CLK _6807_/D VGND VGND VPWR VPWR _6807_/Q sky130_fd_sc_hd__dfxtp_2
Xplace390 _4690_/B VGND VGND VPWR VPWR _5633_/B sky130_fd_sc_hd__buf_2
XFILLER_23_265 VGND VGND VPWR VPWR sky130_fd_sc_hd__decap_3
XFILLER_11_405 VGND VGND VPWR VPWR sky130_fd_sc_hd__decap_3
XFILLER_23_287 VGND VGND VPWR VPWR sky130_fd_sc_hd__decap_3
XFILLER_11_438 VGND VGND VPWR VPWR sky130_fd_sc_hd__decap_3
X_6738_ clkload4/A _6738_/D VGND VGND VPWR VPWR _6738_/Q sky130_fd_sc_hd__dfxtp_2
XTAP_TAPCELL_ROW_102_1594 VGND VPWR sky130_fd_sc_hd__tapvpwrvgnd_1
XFILLER_109_304 VGND VGND VPWR VPWR sky130_fd_sc_hd__decap_3
XFILLER_109_315 VGND VGND VPWR VPWR sky130_fd_sc_hd__decap_3
X_6669_ _6672_/A VGND VGND VPWR VPWR _6669_/Y sky130_fd_sc_hd__inv_2
XFILLER_109_337 VGND VGND VPWR VPWR sky130_fd_sc_hd__decap_3
XFILLER_3_615 VGND VGND VPWR VPWR sky130_fd_sc_hd__fill_1
XFILLER_3_626 VGND VGND VPWR VPWR sky130_fd_sc_hd__decap_3
XFILLER_3_659 VGND VGND VPWR VPWR sky130_fd_sc_hd__decap_3
XFILLER_105_543 VGND VGND VPWR VPWR sky130_fd_sc_hd__decap_3
XFILLER_105_576 VGND VGND VPWR VPWR sky130_fd_sc_hd__decap_3
XFILLER_120_513 VGND VGND VPWR VPWR sky130_fd_sc_hd__decap_3
XFILLER_59_641 VGND VGND VPWR VPWR sky130_fd_sc_hd__decap_3
XFILLER_120_557 VGND VGND VPWR VPWR sky130_fd_sc_hd__decap_3
XFILLER_19_505 VGND VGND VPWR VPWR sky130_fd_sc_hd__decap_3
XFILLER_59_685 VGND VGND VPWR VPWR sky130_fd_sc_hd__decap_3
XFILLER_86_482 VGND VGND VPWR VPWR sky130_fd_sc_hd__decap_3
XFILLER_74_622 VGND VGND VPWR VPWR sky130_fd_sc_hd__decap_3
XFILLER_58_173 VGND VGND VPWR VPWR sky130_fd_sc_hd__decap_3
XFILLER_46_324 VGND VGND VPWR VPWR sky130_fd_sc_hd__decap_3
XFILLER_74_666 VGND VGND VPWR VPWR sky130_fd_sc_hd__decap_3
XFILLER_34_508 VGND VGND VPWR VPWR sky130_fd_sc_hd__decap_3
XFILLER_15_700 VGND VGND VPWR VPWR sky130_fd_sc_hd__decap_3
XFILLER_74_699 VGND VGND VPWR VPWR sky130_fd_sc_hd__fill_1
XFILLER_61_327 VGND VGND VPWR VPWR sky130_fd_sc_hd__decap_3
XFILLER_27_593 VGND VGND VPWR VPWR sky130_fd_sc_hd__decap_3
XFILLER_54_390 VGND VGND VPWR VPWR sky130_fd_sc_hd__decap_3
XFILLER_14_243 VGND VGND VPWR VPWR sky130_fd_sc_hd__decap_3
XFILLER_42_574 VGND VGND VPWR VPWR sky130_fd_sc_hd__decap_3
XFILLER_30_725 VGND VGND VPWR VPWR sky130_fd_sc_hd__decap_3
XTAP_TAPCELL_ROW_64_1099 VGND VPWR sky130_fd_sc_hd__tapvpwrvgnd_1
XFILLER_14_298 VGND VGND VPWR VPWR sky130_fd_sc_hd__fill_2
XTAP_TAPCELL_ROW_12_422 VGND VPWR sky130_fd_sc_hd__tapvpwrvgnd_1
XFILLER_80_85 VGND VGND VPWR VPWR sky130_fd_sc_hd__decap_3
XTAP_TAPCELL_ROW_40_786 VGND VPWR sky130_fd_sc_hd__tapvpwrvgnd_1
XFILLER_6_453 VGND VGND VPWR VPWR sky130_fd_sc_hd__fill_2
XFILLER_115_329 VGND VGND VPWR VPWR sky130_fd_sc_hd__fill_2
XFILLER_6_497 VGND VGND VPWR VPWR sky130_fd_sc_hd__fill_1
XFILLER_89_94 VGND VGND VPWR VPWR sky130_fd_sc_hd__decap_3
XFILLER_97_703 VGND VGND VPWR VPWR sky130_fd_sc_hd__decap_3
XFILLER_69_405 VGND VGND VPWR VPWR sky130_fd_sc_hd__decap_3
XFILLER_123_351 VGND VGND VPWR VPWR sky130_fd_sc_hd__decap_3
XFILLER_2_681 VGND VGND VPWR VPWR sky130_fd_sc_hd__decap_3
XFILLER_69_449 VGND VGND VPWR VPWR sky130_fd_sc_hd__decap_3
XFILLER_96_246 VGND VGND VPWR VPWR sky130_fd_sc_hd__decap_3
XFILLER_111_546 VGND VGND VPWR VPWR sky130_fd_sc_hd__decap_3
X_4020_ _7086_/Q _4102_/B _4432_/B1 _4019_/X VGND VGND VPWR VPWR _4039_/A sky130_fd_sc_hd__o211ai_2
XFILLER_1_191 VGND VGND VPWR VPWR sky130_fd_sc_hd__decap_3
XFILLER_111_579 VGND VGND VPWR VPWR sky130_fd_sc_hd__decap_3
Xclkbuf_leaf_1_clk clkbuf_leaf_1_clk/A VGND VGND VPWR VPWR clkload5/A sky130_fd_sc_hd__clkbuf_16
XFILLER_77_482 VGND VGND VPWR VPWR sky130_fd_sc_hd__decap_3
XFILLER_37_313 VGND VGND VPWR VPWR sky130_fd_sc_hd__decap_3
XFILLER_65_644 VGND VGND VPWR VPWR sky130_fd_sc_hd__decap_3
XFILLER_64_121 VGND VGND VPWR VPWR sky130_fd_sc_hd__decap_3
XFILLER_92_441 VGND VGND VPWR VPWR sky130_fd_sc_hd__decap_3
XFILLER_37_346 VGND VGND VPWR VPWR sky130_fd_sc_hd__decap_3
XFILLER_25_508 VGND VGND VPWR VPWR sky130_fd_sc_hd__fill_2
XFILLER_65_688 VGND VGND VPWR VPWR sky130_fd_sc_hd__decap_3
XFILLER_37_379 VGND VGND VPWR VPWR sky130_fd_sc_hd__decap_3
XTAP_TAPCELL_ROW_48_886 VGND VPWR sky130_fd_sc_hd__tapvpwrvgnd_1
XFILLER_92_474 VGND VGND VPWR VPWR sky130_fd_sc_hd__fill_2
XFILLER_18_560 VGND VGND VPWR VPWR sky130_fd_sc_hd__decap_3
XTAP_TAPCELL_ROW_48_897 VGND VPWR sky130_fd_sc_hd__tapvpwrvgnd_1
XFILLER_80_625 VGND VGND VPWR VPWR sky130_fd_sc_hd__decap_3
X_4922_ _4937_/A _4937_/B _4203_/X VGND VGND VPWR VPWR _4922_/X sky130_fd_sc_hd__a21o_2
XFILLER_52_349 VGND VGND VPWR VPWR sky130_fd_sc_hd__decap_3
XFILLER_80_669 VGND VGND VPWR VPWR sky130_fd_sc_hd__decap_3
XFILLER_21_703 VGND VGND VPWR VPWR sky130_fd_sc_hd__decap_3
XFILLER_100_29 VGND VGND VPWR VPWR sky130_fd_sc_hd__decap_3
XFILLER_60_371 VGND VGND VPWR VPWR sky130_fd_sc_hd__decap_3
XFILLER_33_596 VGND VGND VPWR VPWR sky130_fd_sc_hd__decap_3
X_3804_ _6826_/Q _3884_/A2 _3890_/B1 _6811_/Q _3803_/X VGND VGND VPWR VPWR _3804_/X
+ sky130_fd_sc_hd__a221o_2
X_4784_ _4813_/A _4829_/B VGND VGND VPWR VPWR _4811_/B sky130_fd_sc_hd__nand2_2
XFILLER_20_268 VGND VGND VPWR VPWR sky130_fd_sc_hd__decap_3
X_6523_ _6619_/A VGND VGND VPWR VPWR _6523_/Y sky130_fd_sc_hd__inv_2
XFILLER_119_635 VGND VGND VPWR VPWR sky130_fd_sc_hd__decap_3
X_3735_ _3735_/A _3746_/B _3746_/C VGND VGND VPWR VPWR _3735_/X sky130_fd_sc_hd__and3_4
XTAP_TAPCELL_ROW_95_1505 VGND VPWR sky130_fd_sc_hd__tapvpwrvgnd_1
XFILLER_119_668 VGND VGND VPWR VPWR sky130_fd_sc_hd__decap_3
XFILLER_119_679 VGND VGND VPWR VPWR sky130_fd_sc_hd__decap_3
XFILLER_109_27 VGND VGND VPWR VPWR sky130_fd_sc_hd__decap_3
X_6454_ _6614_/A VGND VGND VPWR VPWR _6454_/Y sky130_fd_sc_hd__inv_2
XFILLER_106_307 VGND VGND VPWR VPWR sky130_fd_sc_hd__fill_1
XFILLER_106_318 VGND VGND VPWR VPWR sky130_fd_sc_hd__decap_3
X_6385_ _6618_/A VGND VGND VPWR VPWR _6385_/Y sky130_fd_sc_hd__inv_2
X_3597_ _4295_/B _3607_/B VGND VGND VPWR VPWR _3611_/B sky130_fd_sc_hd__nor2_2
X_5336_ _5336_/A0 _5040_/X _5340_/S VGND VGND VPWR VPWR _7163_/D sky130_fd_sc_hd__mux2_2
XFILLER_114_351 VGND VGND VPWR VPWR sky130_fd_sc_hd__decap_3
XFILLER_88_725 VGND VGND VPWR VPWR sky130_fd_sc_hd__decap_3
XFILLER_0_629 VGND VGND VPWR VPWR sky130_fd_sc_hd__decap_3
XFILLER_102_557 VGND VGND VPWR VPWR sky130_fd_sc_hd__decap_3
XFILLER_87_257 VGND VGND VPWR VPWR sky130_fd_sc_hd__fill_2
X_7006_ _7370_/CLK _7006_/D _6286_/Y VGND VGND VPWR VPWR _7006_/Q sky130_fd_sc_hd__dfrtp_2
XFILLER_75_408 VGND VGND VPWR VPWR sky130_fd_sc_hd__decap_3
X_4218_ _7100_/Q _4351_/A2 _4267_/A2 _7132_/Q VGND VGND VPWR VPWR _4218_/X sky130_fd_sc_hd__a22o_2
X_5198_ _5198_/A _5207_/B VGND VGND VPWR VPWR _7229_/D sky130_fd_sc_hd__and2_2
XFILLER_56_622 VGND VGND VPWR VPWR sky130_fd_sc_hd__decap_3
XFILLER_28_324 VGND VGND VPWR VPWR sky130_fd_sc_hd__decap_3
X_4149_ _4205_/A _4205_/B VGND VGND VPWR VPWR _4157_/A sky130_fd_sc_hd__nand2_2
XFILLER_83_430 VGND VGND VPWR VPWR sky130_fd_sc_hd__decap_3
XFILLER_83_452 VGND VGND VPWR VPWR sky130_fd_sc_hd__decap_3
XFILLER_56_666 VGND VGND VPWR VPWR sky130_fd_sc_hd__decap_3
XFILLER_28_357 VGND VGND VPWR VPWR sky130_fd_sc_hd__decap_3
XFILLER_28_368 VGND VGND VPWR VPWR sky130_fd_sc_hd__decap_3
XFILLER_55_165 VGND VGND VPWR VPWR sky130_fd_sc_hd__decap_3
XFILLER_56_699 VGND VGND VPWR VPWR sky130_fd_sc_hd__fill_1
XFILLER_55_187 VGND VGND VPWR VPWR sky130_fd_sc_hd__fill_2
XFILLER_71_647 VGND VGND VPWR VPWR sky130_fd_sc_hd__decap_3
XTAP_TAPCELL_ROW_104_1623 VGND VPWR sky130_fd_sc_hd__tapvpwrvgnd_1
XFILLER_70_168 VGND VGND VPWR VPWR sky130_fd_sc_hd__decap_3
XFILLER_24_563 VGND VGND VPWR VPWR sky130_fd_sc_hd__decap_3
XFILLER_34_67 VGND VGND VPWR VPWR sky130_fd_sc_hd__decap_3
XFILLER_12_725 VGND VGND VPWR VPWR sky130_fd_sc_hd__decap_3
XFILLER_51_393 VGND VGND VPWR VPWR sky130_fd_sc_hd__decap_3
XFILLER_8_707 VGND VGND VPWR VPWR sky130_fd_sc_hd__decap_3
Xclkload0 clkload0/A VGND VGND VPWR VPWR clkload0/X sky130_fd_sc_hd__clkbuf_16
XFILLER_7_217 VGND VGND VPWR VPWR sky130_fd_sc_hd__decap_3
XFILLER_50_44 VGND VGND VPWR VPWR sky130_fd_sc_hd__decap_3
XFILLER_109_167 VGND VGND VPWR VPWR sky130_fd_sc_hd__fill_1
XFILLER_50_88 VGND VGND VPWR VPWR sky130_fd_sc_hd__decap_3
XFILLER_3_401 VGND VGND VPWR VPWR sky130_fd_sc_hd__decap_3
XFILLER_118_690 VGND VGND VPWR VPWR sky130_fd_sc_hd__decap_3
XFILLER_3_434 VGND VGND VPWR VPWR sky130_fd_sc_hd__decap_3
XTAP_TAPCELL_ROW_115_1763 VGND VPWR sky130_fd_sc_hd__tapvpwrvgnd_1
XFILLER_79_703 VGND VGND VPWR VPWR sky130_fd_sc_hd__decap_3
XFILLER_105_340 VGND VGND VPWR VPWR sky130_fd_sc_hd__decap_3
XFILLER_3_467 VGND VGND VPWR VPWR sky130_fd_sc_hd__decap_3
XFILLER_59_53 VGND VGND VPWR VPWR sky130_fd_sc_hd__decap_3
XFILLER_3_489 VGND VGND VPWR VPWR sky130_fd_sc_hd__decap_3
XFILLER_105_373 VGND VGND VPWR VPWR sky130_fd_sc_hd__decap_3
XFILLER_78_224 VGND VGND VPWR VPWR sky130_fd_sc_hd__decap_3
XFILLER_94_728 VGND VGND VPWR VPWR sky130_fd_sc_hd__decap_3
XFILLER_66_419 VGND VGND VPWR VPWR sky130_fd_sc_hd__fill_1
XFILLER_120_365 VGND VGND VPWR VPWR sky130_fd_sc_hd__decap_3
XFILLER_19_313 VGND VGND VPWR VPWR sky130_fd_sc_hd__decap_3
XFILLER_120_398 VGND VGND VPWR VPWR sky130_fd_sc_hd__decap_3
XFILLER_115_81 VGND VGND VPWR VPWR sky130_fd_sc_hd__decap_3
XFILLER_59_493 VGND VGND VPWR VPWR sky130_fd_sc_hd__decap_3
XFILLER_47_644 VGND VGND VPWR VPWR sky130_fd_sc_hd__decap_3
XFILLER_19_335 VGND VGND VPWR VPWR sky130_fd_sc_hd__fill_1
XFILLER_75_63 VGND VGND VPWR VPWR sky130_fd_sc_hd__decap_3
XFILLER_75_85 VGND VGND VPWR VPWR sky130_fd_sc_hd__decap_3
XFILLER_74_463 VGND VGND VPWR VPWR sky130_fd_sc_hd__decap_3
XFILLER_62_614 VGND VGND VPWR VPWR sky130_fd_sc_hd__decap_3
XFILLER_47_688 VGND VGND VPWR VPWR sky130_fd_sc_hd__decap_3
XTAP_TAPCELL_ROW_66_1128 VGND VPWR sky130_fd_sc_hd__tapvpwrvgnd_1
XFILLER_34_349 VGND VGND VPWR VPWR sky130_fd_sc_hd__decap_3
XTAP_TAPCELL_ROW_45_856 VGND VPWR sky130_fd_sc_hd__tapvpwrvgnd_1
XFILLER_62_669 VGND VGND VPWR VPWR sky130_fd_sc_hd__decap_3
XFILLER_27_390 VGND VGND VPWR VPWR sky130_fd_sc_hd__fill_2
XFILLER_15_541 VGND VGND VPWR VPWR sky130_fd_sc_hd__decap_3
XFILLER_91_51 VGND VGND VPWR VPWR sky130_fd_sc_hd__decap_3
XFILLER_15_585 VGND VGND VPWR VPWR sky130_fd_sc_hd__decap_3
XFILLER_91_84 VGND VGND VPWR VPWR sky130_fd_sc_hd__decap_3
XFILLER_30_533 VGND VGND VPWR VPWR sky130_fd_sc_hd__decap_3
XTAP_TAPCELL_ROW_25_591 VGND VPWR sky130_fd_sc_hd__tapvpwrvgnd_1
X_3520_ _5118_/D _3354_/X _3519_/Y _3350_/B VGND VGND VPWR VPWR _3525_/B sky130_fd_sc_hd__o2bb2a_2
XFILLER_116_616 VGND VGND VPWR VPWR sky130_fd_sc_hd__decap_3
XFILLER_6_250 VGND VGND VPWR VPWR sky130_fd_sc_hd__fill_2
Xhold707 _6838_/Q VGND VGND VPWR VPWR _6838_/D sky130_fd_sc_hd__dlygate4sd3_1
Xhold718 _6919_/Q VGND VGND VPWR VPWR _6919_/D sky130_fd_sc_hd__dlygate4sd3_1
Xhold729 _6872_/Q VGND VGND VPWR VPWR _6872_/D sky130_fd_sc_hd__dlygate4sd3_1
XTAP_TAPCELL_ROW_77_1268 VGND VPWR sky130_fd_sc_hd__tapvpwrvgnd_1
XFILLER_115_137 VGND VGND VPWR VPWR sky130_fd_sc_hd__decap_3
XFILLER_69_202 VGND VGND VPWR VPWR sky130_fd_sc_hd__decap_3
XTAP_TAPCELL_ROW_90_1435 VGND VPWR sky130_fd_sc_hd__tapvpwrvgnd_1
X_5121_ _5092_/C _5117_/X _5118_/X _6984_/D _5642_/A VGND VGND VPWR VPWR _5121_/X
+ sky130_fd_sc_hd__a32o_2
XFILLER_97_544 VGND VGND VPWR VPWR sky130_fd_sc_hd__decap_3
XFILLER_69_246 VGND VGND VPWR VPWR sky130_fd_sc_hd__decap_3
XFILLER_111_332 VGND VGND VPWR VPWR sky130_fd_sc_hd__decap_3
XFILLER_85_706 VGND VGND VPWR VPWR sky130_fd_sc_hd__decap_3
XFILLER_111_343 VGND VGND VPWR VPWR sky130_fd_sc_hd__fill_2
X_5052_ _4948_/A _5049_/X _5051_/X _3618_/X VGND VGND VPWR VPWR _5052_/X sky130_fd_sc_hd__a2bb2o_2
XFILLER_97_588 VGND VGND VPWR VPWR sky130_fd_sc_hd__decap_3
XFILLER_111_365 VGND VGND VPWR VPWR sky130_fd_sc_hd__fill_1
XFILLER_38_622 VGND VGND VPWR VPWR sky130_fd_sc_hd__decap_3
XFILLER_84_238 VGND VGND VPWR VPWR sky130_fd_sc_hd__decap_3
XFILLER_77_290 VGND VGND VPWR VPWR sky130_fd_sc_hd__decap_3
XFILLER_65_452 VGND VGND VPWR VPWR sky130_fd_sc_hd__decap_3
XFILLER_38_666 VGND VGND VPWR VPWR sky130_fd_sc_hd__decap_3
XFILLER_53_603 VGND VGND VPWR VPWR sky130_fd_sc_hd__decap_3
XFILLER_80_400 VGND VGND VPWR VPWR sky130_fd_sc_hd__decap_3
XFILLER_38_699 VGND VGND VPWR VPWR sky130_fd_sc_hd__fill_1
XFILLER_92_271 VGND VGND VPWR VPWR sky130_fd_sc_hd__decap_3
XFILLER_53_647 VGND VGND VPWR VPWR sky130_fd_sc_hd__decap_3
XFILLER_111_39 VGND VGND VPWR VPWR sky130_fd_sc_hd__decap_3
X_4905_ _4970_/A1 _4888_/A _4903_/A _5101_/A VGND VGND VPWR VPWR _4905_/X sky130_fd_sc_hd__o2bb2a_2
XFILLER_61_691 VGND VGND VPWR VPWR sky130_fd_sc_hd__decap_3
XFILLER_33_393 VGND VGND VPWR VPWR sky130_fd_sc_hd__decap_3
X_4836_ _7001_/D _4835_/X _5040_/S VGND VGND VPWR VPWR _4836_/X sky130_fd_sc_hd__mux2_2
XFILLER_21_577 VGND VGND VPWR VPWR sky130_fd_sc_hd__decap_3
X_4767_ _5057_/A _4452_/A _4453_/A _4852_/A _4766_/Y VGND VGND VPWR VPWR _4767_/X
+ sky130_fd_sc_hd__o221a_2
XFILLER_119_454 VGND VGND VPWR VPWR sky130_fd_sc_hd__decap_3
X_6506_ _6570_/A VGND VGND VPWR VPWR _6506_/Y sky130_fd_sc_hd__inv_2
XFILLER_4_209 VGND VGND VPWR VPWR sky130_fd_sc_hd__decap_3
X_4698_ _6985_/Q _5120_/A VGND VGND VPWR VPWR _5098_/A sky130_fd_sc_hd__and2_2
XFILLER_119_487 VGND VGND VPWR VPWR sky130_fd_sc_hd__decap_3
XFILLER_107_638 VGND VGND VPWR VPWR sky130_fd_sc_hd__decap_3
X_6437_ _6596_/A VGND VGND VPWR VPWR _6437_/Y sky130_fd_sc_hd__inv_2
XFILLER_122_619 VGND VGND VPWR VPWR sky130_fd_sc_hd__decap_3
X_6368_ _6635_/A VGND VGND VPWR VPWR _6368_/Y sky130_fd_sc_hd__inv_2
XFILLER_115_671 VGND VGND VPWR VPWR sky130_fd_sc_hd__fill_1
XFILLER_96_29 VGND VGND VPWR VPWR sky130_fd_sc_hd__decap_3
XFILLER_115_682 VGND VGND VPWR VPWR sky130_fd_sc_hd__decap_3
XFILLER_88_533 VGND VGND VPWR VPWR sky130_fd_sc_hd__decap_3
XFILLER_114_170 VGND VGND VPWR VPWR sky130_fd_sc_hd__decap_3
X_5319_ _5319_/A0 _4913_/X _5344_/S VGND VGND VPWR VPWR _7171_/D sky130_fd_sc_hd__mux2_2
XFILLER_88_544 VGND VGND VPWR VPWR sky130_fd_sc_hd__decap_3
X_6299_ _6680_/A VGND VGND VPWR VPWR _6299_/Y sky130_fd_sc_hd__inv_2
XFILLER_29_23 VGND VGND VPWR VPWR sky130_fd_sc_hd__decap_3
XFILLER_88_577 VGND VGND VPWR VPWR sky130_fd_sc_hd__decap_3
XFILLER_76_728 VGND VGND VPWR VPWR sky130_fd_sc_hd__decap_3
XFILLER_75_205 VGND VGND VPWR VPWR sky130_fd_sc_hd__fill_2
XFILLER_102_365 VGND VGND VPWR VPWR sky130_fd_sc_hd__decap_3
XTAP_TAPCELL_ROW_110_1693 VGND VPWR sky130_fd_sc_hd__tapvpwrvgnd_1
XFILLER_102_398 VGND VGND VPWR VPWR sky130_fd_sc_hd__decap_3
XFILLER_91_709 VGND VGND VPWR VPWR sky130_fd_sc_hd__decap_3
XFILLER_56_430 VGND VGND VPWR VPWR sky130_fd_sc_hd__decap_3
XFILLER_29_644 VGND VGND VPWR VPWR sky130_fd_sc_hd__decap_3
XFILLER_28_121 VGND VGND VPWR VPWR sky130_fd_sc_hd__fill_2
XFILLER_90_208 VGND VGND VPWR VPWR sky130_fd_sc_hd__decap_3
XFILLER_56_463 VGND VGND VPWR VPWR sky130_fd_sc_hd__decap_3
XFILLER_29_688 VGND VGND VPWR VPWR sky130_fd_sc_hd__decap_3
XFILLER_28_165 VGND VGND VPWR VPWR sky130_fd_sc_hd__fill_2
XFILLER_16_305 VGND VGND VPWR VPWR sky130_fd_sc_hd__decap_3
XFILLER_44_636 VGND VGND VPWR VPWR sky130_fd_sc_hd__decap_3
XFILLER_43_113 VGND VGND VPWR VPWR sky130_fd_sc_hd__decap_3
XFILLER_16_327 VGND VGND VPWR VPWR sky130_fd_sc_hd__decap_3
XFILLER_83_293 VGND VGND VPWR VPWR sky130_fd_sc_hd__decap_3
XFILLER_16_349 VGND VGND VPWR VPWR sky130_fd_sc_hd__decap_3
XFILLER_44_669 VGND VGND VPWR VPWR sky130_fd_sc_hd__decap_3
XFILLER_31_308 VGND VGND VPWR VPWR sky130_fd_sc_hd__decap_3
XTAP_TAPCELL_ROW_42_815 VGND VPWR sky130_fd_sc_hd__tapvpwrvgnd_1
XFILLER_71_488 VGND VGND VPWR VPWR sky130_fd_sc_hd__decap_3
XFILLER_24_360 VGND VGND VPWR VPWR sky130_fd_sc_hd__decap_3
XFILLER_24_371 VGND VGND VPWR VPWR sky130_fd_sc_hd__fill_1
XFILLER_12_544 VGND VGND VPWR VPWR sky130_fd_sc_hd__decap_3
XFILLER_8_504 VGND VGND VPWR VPWR sky130_fd_sc_hd__decap_3
XFILLER_101_94 VGND VGND VPWR VPWR sky130_fd_sc_hd__decap_3
XTAP_TAPCELL_ROW_61_1058 VGND VPWR sky130_fd_sc_hd__tapvpwrvgnd_1
XTAP_TAPCELL_ROW_22_550 VGND VPWR sky130_fd_sc_hd__tapvpwrvgnd_1
XFILLER_12_577 VGND VGND VPWR VPWR sky130_fd_sc_hd__decap_3
XFILLER_8_548 VGND VGND VPWR VPWR sky130_fd_sc_hd__decap_3
XFILLER_6_27 VGND VGND VPWR VPWR sky130_fd_sc_hd__fill_1
XANTENNA_9 _3331_/A VGND VGND VPWR VPWR sky130_fd_sc_hd__diode_2
XFILLER_6_49 VGND VGND VPWR VPWR sky130_fd_sc_hd__decap_3
XFILLER_4_710 VGND VGND VPWR VPWR sky130_fd_sc_hd__decap_3
XFILLER_3_231 VGND VGND VPWR VPWR sky130_fd_sc_hd__decap_3
XFILLER_106_660 VGND VGND VPWR VPWR sky130_fd_sc_hd__decap_3
XFILLER_79_500 VGND VGND VPWR VPWR sky130_fd_sc_hd__decap_3
XFILLER_106_693 VGND VGND VPWR VPWR sky130_fd_sc_hd__decap_3
XFILLER_79_555 VGND VGND VPWR VPWR sky130_fd_sc_hd__decap_3
XFILLER_121_641 VGND VGND VPWR VPWR sky130_fd_sc_hd__decap_3
XFILLER_105_192 VGND VGND VPWR VPWR sky130_fd_sc_hd__decap_3
XFILLER_67_706 VGND VGND VPWR VPWR sky130_fd_sc_hd__decap_3
XTAP_TAPCELL_ROW_72_1198 VGND VPWR sky130_fd_sc_hd__tapvpwrvgnd_1
XFILLER_94_514 VGND VGND VPWR VPWR sky130_fd_sc_hd__fill_2
XFILLER_79_588 VGND VGND VPWR VPWR sky130_fd_sc_hd__decap_3
XFILLER_94_525 VGND VGND VPWR VPWR sky130_fd_sc_hd__decap_3
XFILLER_121_685 VGND VGND VPWR VPWR sky130_fd_sc_hd__decap_3
XFILLER_120_173 VGND VGND VPWR VPWR sky130_fd_sc_hd__fill_2
XFILLER_47_430 VGND VGND VPWR VPWR sky130_fd_sc_hd__decap_3
XFILLER_47_452 VGND VGND VPWR VPWR sky130_fd_sc_hd__fill_1
XFILLER_35_603 VGND VGND VPWR VPWR sky130_fd_sc_hd__decap_3
XFILLER_62_400 VGND VGND VPWR VPWR sky130_fd_sc_hd__decap_3
XFILLER_47_485 VGND VGND VPWR VPWR sky130_fd_sc_hd__decap_3
XFILLER_74_271 VGND VGND VPWR VPWR sky130_fd_sc_hd__fill_2
XFILLER_90_731 VGND VGND VPWR VPWR sky130_fd_sc_hd__decap_3
XFILLER_74_293 VGND VGND VPWR VPWR sky130_fd_sc_hd__decap_3
XFILLER_62_433 VGND VGND VPWR VPWR sky130_fd_sc_hd__decap_3
XFILLER_35_647 VGND VGND VPWR VPWR sky130_fd_sc_hd__decap_3
XFILLER_34_124 VGND VGND VPWR VPWR sky130_fd_sc_hd__decap_3
XFILLER_62_466 VGND VGND VPWR VPWR sky130_fd_sc_hd__decap_3
XFILLER_50_628 VGND VGND VPWR VPWR sky130_fd_sc_hd__decap_3
XFILLER_22_319 VGND VGND VPWR VPWR sky130_fd_sc_hd__decap_3
XFILLER_43_691 VGND VGND VPWR VPWR sky130_fd_sc_hd__decap_3
XFILLER_15_393 VGND VGND VPWR VPWR sky130_fd_sc_hd__decap_3
X_5670_ _5670_/A _5670_/B VGND VGND VPWR VPWR _5671_/B sky130_fd_sc_hd__nand2_2
XFILLER_89_3 VGND VGND VPWR VPWR sky130_fd_sc_hd__decap_3
XFILLER_30_352 VGND VGND VPWR VPWR sky130_fd_sc_hd__decap_3
X_4621_ _4315_/B _4343_/X _4315_/A VGND VGND VPWR VPWR _4621_/X sky130_fd_sc_hd__a21bo_2
XFILLER_30_374 VGND VGND VPWR VPWR sky130_fd_sc_hd__decap_3
X_7340_ _7372_/CLK _7340_/D _6620_/Y VGND VGND VPWR VPWR _7340_/Q sky130_fd_sc_hd__dfrtp_2
X_4552_ _4552_/A _4559_/B VGND VGND VPWR VPWR _7304_/D sky130_fd_sc_hd__and2_2
XFILLER_116_413 VGND VGND VPWR VPWR sky130_fd_sc_hd__decap_3
XFILLER_7_570 VGND VGND VPWR VPWR sky130_fd_sc_hd__decap_3
XFILLER_116_424 VGND VGND VPWR VPWR sky130_fd_sc_hd__decap_3
X_3503_ _3545_/A _3545_/B VGND VGND VPWR VPWR _3630_/A sky130_fd_sc_hd__xor2_4
X_7271_ _7399_/CLK _7271_/D _6551_/Y VGND VGND VPWR VPWR _7271_/Q sky130_fd_sc_hd__dfrtp_2
XFILLER_89_308 VGND VGND VPWR VPWR sky130_fd_sc_hd__decap_3
XFILLER_104_619 VGND VGND VPWR VPWR sky130_fd_sc_hd__decap_3
X_3434_ _7218_/Q _4349_/B1 _4341_/B1 _7122_/Q VGND VGND VPWR VPWR _3434_/X sky130_fd_sc_hd__a22o_2
XFILLER_89_319 VGND VGND VPWR VPWR sky130_fd_sc_hd__decap_3
X_3365_ _6980_/Q VGND VGND VPWR VPWR _5118_/A sky130_fd_sc_hd__inv_2
XFILLER_97_352 VGND VGND VPWR VPWR sky130_fd_sc_hd__decap_3
XFILLER_112_663 VGND VGND VPWR VPWR sky130_fd_sc_hd__decap_3
X_5104_ _5104_/A _5660_/C VGND VGND VPWR VPWR _5104_/Y sky130_fd_sc_hd__nand2_2
XFILLER_58_728 VGND VGND VPWR VPWR sky130_fd_sc_hd__decap_3
Xhold1204 _7151_/Q VGND VGND VPWR VPWR _5360_/A0 sky130_fd_sc_hd__dlygate4sd3_1
XFILLER_85_525 VGND VGND VPWR VPWR sky130_fd_sc_hd__fill_2
Xhold1215 _7126_/Q VGND VGND VPWR VPWR _5415_/A0 sky130_fd_sc_hd__dlygate4sd3_1
XFILLER_112_696 VGND VGND VPWR VPWR sky130_fd_sc_hd__decap_3
XFILLER_111_184 VGND VGND VPWR VPWR sky130_fd_sc_hd__decap_3
XFILLER_57_249 VGND VGND VPWR VPWR sky130_fd_sc_hd__decap_3
XFILLER_73_709 VGND VGND VPWR VPWR sky130_fd_sc_hd__decap_3
XFILLER_38_430 VGND VGND VPWR VPWR sky130_fd_sc_hd__decap_3
XFILLER_38_452 VGND VGND VPWR VPWR sky130_fd_sc_hd__decap_3
XFILLER_38_474 VGND VGND VPWR VPWR sky130_fd_sc_hd__fill_2
XFILLER_122_38 VGND VGND VPWR VPWR sky130_fd_sc_hd__decap_3
XFILLER_26_625 VGND VGND VPWR VPWR sky130_fd_sc_hd__decap_3
XFILLER_38_485 VGND VGND VPWR VPWR sky130_fd_sc_hd__decap_3
XPHY_EDGE_ROW_69_Left_193 VGND VGND VPWR VPWR sky130_fd_sc_hd__decap_3
XFILLER_93_591 VGND VGND VPWR VPWR sky130_fd_sc_hd__decap_3
XFILLER_25_113 VGND VGND VPWR VPWR sky130_fd_sc_hd__fill_1
XFILLER_65_293 VGND VGND VPWR VPWR sky130_fd_sc_hd__fill_1
XFILLER_53_433 VGND VGND VPWR VPWR sky130_fd_sc_hd__decap_3
XTAP_TAPCELL_ROW_0_256 VGND VPWR sky130_fd_sc_hd__tapvpwrvgnd_1
XTAP_TAPCELL_ROW_0_267 VGND VPWR sky130_fd_sc_hd__tapvpwrvgnd_1
XFILLER_26_669 VGND VGND VPWR VPWR sky130_fd_sc_hd__decap_3
X_6986_ _7386_/CLK _6986_/D _6266_/Y VGND VGND VPWR VPWR _6986_/Q sky130_fd_sc_hd__dfrtp_2
XFILLER_41_617 VGND VGND VPWR VPWR sky130_fd_sc_hd__decap_3
XFILLER_13_308 VGND VGND VPWR VPWR sky130_fd_sc_hd__decap_3
XFILLER_80_274 VGND VGND VPWR VPWR sky130_fd_sc_hd__decap_3
XFILLER_21_330 VGND VGND VPWR VPWR sky130_fd_sc_hd__decap_3
X_4819_ _7002_/Q _4834_/A _4818_/Y _5015_/A VGND VGND VPWR VPWR _4819_/X sky130_fd_sc_hd__o211a_2
XFILLER_31_57 VGND VGND VPWR VPWR sky130_fd_sc_hd__decap_3
XFILLER_110_6 VGND VGND VPWR VPWR sky130_fd_sc_hd__decap_3
XFILLER_119_284 VGND VGND VPWR VPWR sky130_fd_sc_hd__decap_3
XFILLER_107_446 VGND VGND VPWR VPWR sky130_fd_sc_hd__fill_2
XTAP_TAPCELL_ROW_112_1722 VGND VPWR sky130_fd_sc_hd__tapvpwrvgnd_1
XFILLER_122_438 VGND VGND VPWR VPWR sky130_fd_sc_hd__decap_3
XFILLER_0_212 VGND VGND VPWR VPWR sky130_fd_sc_hd__fill_1
XTAP_TAPCELL_ROW_8_367 VGND VPWR sky130_fd_sc_hd__tapvpwrvgnd_1
XFILLER_103_641 VGND VGND VPWR VPWR sky130_fd_sc_hd__decap_3
XFILLER_0_234 VGND VGND VPWR VPWR sky130_fd_sc_hd__decap_3
XFILLER_88_341 VGND VGND VPWR VPWR sky130_fd_sc_hd__decap_3
XFILLER_0_245 VGND VGND VPWR VPWR sky130_fd_sc_hd__decap_3
XFILLER_49_706 VGND VGND VPWR VPWR sky130_fd_sc_hd__decap_3
XFILLER_0_256 VGND VGND VPWR VPWR sky130_fd_sc_hd__decap_3
XFILLER_88_374 VGND VGND VPWR VPWR sky130_fd_sc_hd__decap_3
XFILLER_103_685 VGND VGND VPWR VPWR sky130_fd_sc_hd__decap_3
XFILLER_76_547 VGND VGND VPWR VPWR sky130_fd_sc_hd__fill_2
XFILLER_48_238 VGND VGND VPWR VPWR sky130_fd_sc_hd__fill_1
XFILLER_29_441 VGND VGND VPWR VPWR sky130_fd_sc_hd__decap_3
XFILLER_29_452 VGND VGND VPWR VPWR sky130_fd_sc_hd__fill_1
XFILLER_17_603 VGND VGND VPWR VPWR sky130_fd_sc_hd__decap_3
XFILLER_72_731 VGND VGND VPWR VPWR sky130_fd_sc_hd__decap_3
XTAP_TAPCELL_ROW_27_620 VGND VPWR sky130_fd_sc_hd__tapvpwrvgnd_1
XFILLER_17_647 VGND VGND VPWR VPWR sky130_fd_sc_hd__decap_3
XFILLER_44_433 VGND VGND VPWR VPWR sky130_fd_sc_hd__decap_3
XPHY_EDGE_ROW_19_Right_19 VGND VGND VPWR VPWR sky130_fd_sc_hd__decap_3
XFILLER_72_20 VGND VGND VPWR VPWR sky130_fd_sc_hd__decap_3
XFILLER_71_252 VGND VGND VPWR VPWR sky130_fd_sc_hd__decap_3
XFILLER_44_477 VGND VGND VPWR VPWR sky130_fd_sc_hd__decap_3
XFILLER_112_71 VGND VGND VPWR VPWR sky130_fd_sc_hd__decap_3
XTAP_TAPCELL_ROW_55_984 VGND VPWR sky130_fd_sc_hd__tapvpwrvgnd_1
XFILLER_32_628 VGND VGND VPWR VPWR sky130_fd_sc_hd__decap_3
XFILLER_112_82 VGND VGND VPWR VPWR sky130_fd_sc_hd__fill_2
XTAP_TAPCELL_ROW_123_1862 VGND VPWR sky130_fd_sc_hd__tapvpwrvgnd_1
XFILLER_71_274 VGND VGND VPWR VPWR sky130_fd_sc_hd__fill_1
XTAP_TAPCELL_ROW_123_1873 VGND VPWR sky130_fd_sc_hd__tapvpwrvgnd_1
XFILLER_44_499 VGND VGND VPWR VPWR sky130_fd_sc_hd__decap_3
XTAP_TAPCELL_ROW_123_1884 VGND VPWR sky130_fd_sc_hd__tapvpwrvgnd_1
XFILLER_71_296 VGND VGND VPWR VPWR sky130_fd_sc_hd__decap_3
XFILLER_25_691 VGND VGND VPWR VPWR sky130_fd_sc_hd__decap_3
XFILLER_72_97 VGND VGND VPWR VPWR sky130_fd_sc_hd__decap_3
XFILLER_12_352 VGND VGND VPWR VPWR sky130_fd_sc_hd__decap_3
XFILLER_40_672 VGND VGND VPWR VPWR sky130_fd_sc_hd__decap_3
XFILLER_75_9 VGND VGND VPWR VPWR sky130_fd_sc_hd__decap_3
Xclkbuf_3_1__f_clk clkbuf_0_clk/X VGND VGND VPWR VPWR clkload0/A sky130_fd_sc_hd__clkbuf_16
XPHY_EDGE_ROW_28_Right_28 VGND VGND VPWR VPWR sky130_fd_sc_hd__decap_3
XFILLER_99_606 VGND VGND VPWR VPWR sky130_fd_sc_hd__decap_3
XFILLER_99_617 VGND VGND VPWR VPWR sky130_fd_sc_hd__decap_3
XTAP_TAPCELL_ROW_74_1227 VGND VPWR sky130_fd_sc_hd__tapvpwrvgnd_1
XFILLER_4_551 VGND VGND VPWR VPWR sky130_fd_sc_hd__decap_3
XFILLER_113_405 VGND VGND VPWR VPWR sky130_fd_sc_hd__decap_3
XFILLER_113_427 VGND VGND VPWR VPWR sky130_fd_sc_hd__decap_3
XFILLER_4_584 VGND VGND VPWR VPWR sky130_fd_sc_hd__decap_3
XFILLER_97_50 VGND VGND VPWR VPWR sky130_fd_sc_hd__decap_3
XFILLER_4_595 VGND VGND VPWR VPWR sky130_fd_sc_hd__decap_3
XFILLER_113_449 VGND VGND VPWR VPWR sky130_fd_sc_hd__fill_1
XFILLER_67_503 VGND VGND VPWR VPWR sky130_fd_sc_hd__fill_1
XFILLER_94_300 VGND VGND VPWR VPWR sky130_fd_sc_hd__decap_3
XFILLER_67_514 VGND VGND VPWR VPWR sky130_fd_sc_hd__fill_2
XFILLER_79_396 VGND VGND VPWR VPWR sky130_fd_sc_hd__decap_3
XFILLER_121_482 VGND VGND VPWR VPWR sky130_fd_sc_hd__decap_3
XFILLER_39_249 VGND VGND VPWR VPWR sky130_fd_sc_hd__decap_3
XFILLER_94_355 VGND VGND VPWR VPWR sky130_fd_sc_hd__fill_1
XFILLER_55_709 VGND VGND VPWR VPWR sky130_fd_sc_hd__decap_3
XFILLER_54_208 VGND VGND VPWR VPWR sky130_fd_sc_hd__decap_3
XPHY_EDGE_ROW_37_Right_37 VGND VGND VPWR VPWR sky130_fd_sc_hd__decap_3
XFILLER_75_591 VGND VGND VPWR VPWR sky130_fd_sc_hd__decap_3
X_6840_ _6967_/CLK _6840_/D VGND VGND VPWR VPWR _6840_/Q sky130_fd_sc_hd__dfxtp_2
XFILLER_62_241 VGND VGND VPWR VPWR sky130_fd_sc_hd__decap_3
XTAP_TAPCELL_ROW_85_1367 VGND VPWR sky130_fd_sc_hd__tapvpwrvgnd_1
XTAP_TAPCELL_ROW_85_1378 VGND VPWR sky130_fd_sc_hd__tapvpwrvgnd_1
XFILLER_90_572 VGND VGND VPWR VPWR sky130_fd_sc_hd__decap_3
XFILLER_23_617 VGND VGND VPWR VPWR sky130_fd_sc_hd__decap_3
XFILLER_50_414 VGND VGND VPWR VPWR sky130_fd_sc_hd__fill_2
X_6771_ _6978_/CLK _6771_/D VGND VGND VPWR VPWR _6771_/Q sky130_fd_sc_hd__dfxtp_2
XFILLER_22_116 VGND VGND VPWR VPWR sky130_fd_sc_hd__decap_3
X_3983_ _7349_/Q _4524_/A0 _3987_/S VGND VGND VPWR VPWR _7349_/D sky130_fd_sc_hd__mux2_2
XFILLER_50_436 VGND VGND VPWR VPWR sky130_fd_sc_hd__decap_3
XFILLER_22_149 VGND VGND VPWR VPWR sky130_fd_sc_hd__decap_3
XFILLER_31_650 VGND VGND VPWR VPWR sky130_fd_sc_hd__decap_3
X_5653_ _5664_/B VGND VGND VPWR VPWR _5653_/Y sky130_fd_sc_hd__inv_2
XFILLER_31_694 VGND VGND VPWR VPWR sky130_fd_sc_hd__decap_3
XFILLER_30_193 VGND VGND VPWR VPWR sky130_fd_sc_hd__decap_3
X_4604_ _4667_/B VGND VGND VPWR VPWR _4671_/B sky130_fd_sc_hd__inv_2
XFILLER_117_700 VGND VGND VPWR VPWR sky130_fd_sc_hd__decap_3
XPHY_EDGE_ROW_46_Right_46 VGND VGND VPWR VPWR sky130_fd_sc_hd__decap_3
X_7323_ _7355_/CLK _7323_/D _6603_/Y VGND VGND VPWR VPWR _7323_/Q sky130_fd_sc_hd__dfrtp_2
XFILLER_117_27 VGND VGND VPWR VPWR sky130_fd_sc_hd__decap_3
X_7254_ _7352_/CLK _7254_/D _6534_/Y VGND VGND VPWR VPWR _7254_/Q sky130_fd_sc_hd__dfrtp_2
X_4466_ _5104_/A _5650_/A VGND VGND VPWR VPWR _4466_/Y sky130_fd_sc_hd__nand2_2
XFILLER_89_116 VGND VGND VPWR VPWR sky130_fd_sc_hd__decap_3
XFILLER_104_427 VGND VGND VPWR VPWR sky130_fd_sc_hd__fill_1
X_3417_ _3449_/B _3421_/C _3417_/C VGND VGND VPWR VPWR _3417_/X sky130_fd_sc_hd__and3_2
X_7185_ _7313_/CLK _7185_/D _6465_/Y VGND VGND VPWR VPWR _7185_/Q sky130_fd_sc_hd__dfrtp_2
X_4397_ _4397_/A _4648_/A VGND VGND VPWR VPWR _4795_/A sky130_fd_sc_hd__nor2_2
XFILLER_98_672 VGND VGND VPWR VPWR sky130_fd_sc_hd__decap_3
XFILLER_58_503 VGND VGND VPWR VPWR sky130_fd_sc_hd__decap_3
XTAP_TAPCELL_ROW_5_326 VGND VPWR sky130_fd_sc_hd__tapvpwrvgnd_1
XTAP_TAPCELL_ROW_5_337 VGND VPWR sky130_fd_sc_hd__tapvpwrvgnd_1
X_3348_ _6981_/Q _3327_/B _3386_/A VGND VGND VPWR VPWR _5130_/A sky130_fd_sc_hd__a21oi_2
Xhold1001 _7198_/Q VGND VGND VPWR VPWR _5264_/A0 sky130_fd_sc_hd__dlygate4sd3_1
XFILLER_85_311 VGND VGND VPWR VPWR sky130_fd_sc_hd__decap_3
XFILLER_100_622 VGND VGND VPWR VPWR sky130_fd_sc_hd__decap_3
Xhold1012 _7186_/Q VGND VGND VPWR VPWR _5286_/A0 sky130_fd_sc_hd__dlygate4sd3_1
Xhold1023 _7187_/Q VGND VGND VPWR VPWR _5284_/A0 sky130_fd_sc_hd__dlygate4sd3_1
Xhold1034 _7255_/Q VGND VGND VPWR VPWR _5108_/A0 sky130_fd_sc_hd__dlygate4sd3_1
XPHY_EDGE_ROW_55_Right_55 VGND VGND VPWR VPWR sky130_fd_sc_hd__decap_3
XPHY_EDGE_ROW_77_Left_201 VGND VGND VPWR VPWR sky130_fd_sc_hd__decap_3
Xhold1045 _7214_/Q VGND VGND VPWR VPWR _5232_/A0 sky130_fd_sc_hd__dlygate4sd3_1
XFILLER_100_666 VGND VGND VPWR VPWR sky130_fd_sc_hd__decap_3
Xhold1056 _7402_/Q VGND VGND VPWR VPWR _3698_/A1 sky130_fd_sc_hd__dlygate4sd3_1
Xhold1067 _7222_/Q VGND VGND VPWR VPWR _5213_/A sky130_fd_sc_hd__dlygate4sd3_1
XFILLER_85_377 VGND VGND VPWR VPWR sky130_fd_sc_hd__decap_3
XFILLER_45_208 VGND VGND VPWR VPWR sky130_fd_sc_hd__decap_3
X_5018_ _5018_/A _5018_/B VGND VGND VPWR VPWR _5018_/Y sky130_fd_sc_hd__nor2_2
Xhold1078 _7212_/Q VGND VGND VPWR VPWR _5236_/A0 sky130_fd_sc_hd__dlygate4sd3_1
XFILLER_100_699 VGND VGND VPWR VPWR sky130_fd_sc_hd__fill_1
Xhold1089 _7218_/Q VGND VGND VPWR VPWR _5221_/A sky130_fd_sc_hd__dlygate4sd3_1
XFILLER_38_271 VGND VGND VPWR VPWR sky130_fd_sc_hd__decap_3
XFILLER_54_731 VGND VGND VPWR VPWR sky130_fd_sc_hd__decap_3
XFILLER_53_252 VGND VGND VPWR VPWR sky130_fd_sc_hd__fill_1
XFILLER_26_477 VGND VGND VPWR VPWR sky130_fd_sc_hd__decap_3
XFILLER_14_628 VGND VGND VPWR VPWR sky130_fd_sc_hd__decap_3
XFILLER_81_594 VGND VGND VPWR VPWR sky130_fd_sc_hd__decap_3
X_6969_ _7215_/CLK _6969_/D VGND VGND VPWR VPWR _6969_/Q sky130_fd_sc_hd__dfxtp_2
XFILLER_53_296 VGND VGND VPWR VPWR sky130_fd_sc_hd__decap_3
XFILLER_13_127 VGND VGND VPWR VPWR sky130_fd_sc_hd__decap_3
XTAP_TAPCELL_ROW_52_943 VGND VPWR sky130_fd_sc_hd__tapvpwrvgnd_1
XFILLER_41_447 VGND VGND VPWR VPWR sky130_fd_sc_hd__fill_1
XFILLER_42_23 VGND VGND VPWR VPWR sky130_fd_sc_hd__decap_3
XFILLER_22_672 VGND VGND VPWR VPWR sky130_fd_sc_hd__decap_3
XPHY_EDGE_ROW_64_Right_64 VGND VGND VPWR VPWR sky130_fd_sc_hd__decap_3
XPHY_EDGE_ROW_86_Left_210 VGND VGND VPWR VPWR sky130_fd_sc_hd__decap_3
XFILLER_42_78 VGND VGND VPWR VPWR sky130_fd_sc_hd__decap_3
XFILLER_108_722 VGND VGND VPWR VPWR sky130_fd_sc_hd__decap_3
XFILLER_5_337 VGND VGND VPWR VPWR sky130_fd_sc_hd__decap_3
XFILLER_123_725 VGND VGND VPWR VPWR sky130_fd_sc_hd__decap_3
XFILLER_107_287 VGND VGND VPWR VPWR sky130_fd_sc_hd__fill_1
XFILLER_107_298 VGND VGND VPWR VPWR sky130_fd_sc_hd__decap_3
XFILLER_1_532 VGND VGND VPWR VPWR sky130_fd_sc_hd__decap_3
XFILLER_3_17 VGND VGND VPWR VPWR sky130_fd_sc_hd__decap_3
Xhold890 _7103_/Q VGND VGND VPWR VPWR _7103_/D sky130_fd_sc_hd__dlygate4sd3_1
XFILLER_89_650 VGND VGND VPWR VPWR sky130_fd_sc_hd__decap_3
XFILLER_49_503 VGND VGND VPWR VPWR sky130_fd_sc_hd__fill_1
XFILLER_49_514 VGND VGND VPWR VPWR sky130_fd_sc_hd__fill_2
XFILLER_1_576 VGND VGND VPWR VPWR sky130_fd_sc_hd__decap_3
XFILLER_89_694 VGND VGND VPWR VPWR sky130_fd_sc_hd__decap_3
XFILLER_67_42 VGND VGND VPWR VPWR sky130_fd_sc_hd__decap_3
XFILLER_49_525 VGND VGND VPWR VPWR sky130_fd_sc_hd__fill_1
XPHY_EDGE_ROW_73_Right_73 VGND VGND VPWR VPWR sky130_fd_sc_hd__decap_3
XFILLER_37_709 VGND VGND VPWR VPWR sky130_fd_sc_hd__decap_3
XFILLER_76_377 VGND VGND VPWR VPWR sky130_fd_sc_hd__decap_3
XFILLER_64_517 VGND VGND VPWR VPWR sky130_fd_sc_hd__decap_3
XFILLER_29_293 VGND VGND VPWR VPWR sky130_fd_sc_hd__fill_2
XFILLER_60_701 VGND VGND VPWR VPWR sky130_fd_sc_hd__decap_3
XFILLER_83_74 VGND VGND VPWR VPWR sky130_fd_sc_hd__decap_3
XFILLER_60_734 VGND VGND VPWR VPWR sky130_fd_sc_hd__fill_1
XFILLER_32_447 VGND VGND VPWR VPWR sky130_fd_sc_hd__decap_3
XFILLER_13_650 VGND VGND VPWR VPWR sky130_fd_sc_hd__decap_3
XPHY_EDGE_ROW_82_Right_82 VGND VGND VPWR VPWR sky130_fd_sc_hd__decap_3
XFILLER_9_632 VGND VGND VPWR VPWR sky130_fd_sc_hd__decap_3
XFILLER_13_694 VGND VGND VPWR VPWR sky130_fd_sc_hd__decap_3
XFILLER_12_171 VGND VGND VPWR VPWR sky130_fd_sc_hd__decap_3
XFILLER_9_665 VGND VGND VPWR VPWR sky130_fd_sc_hd__decap_3
XTAP_TAPCELL_ROW_30_659 VGND VPWR sky130_fd_sc_hd__tapvpwrvgnd_1
XFILLER_73_6 VGND VGND VPWR VPWR sky130_fd_sc_hd__decap_3
XFILLER_118_519 VGND VGND VPWR VPWR sky130_fd_sc_hd__decap_3
XFILLER_9_676 VGND VGND VPWR VPWR sky130_fd_sc_hd__decap_3
XFILLER_8_175 VGND VGND VPWR VPWR sky130_fd_sc_hd__fill_2
XFILLER_8_197 VGND VGND VPWR VPWR sky130_fd_sc_hd__decap_3
XTAP_TAPCELL_ROW_10_394 VGND VPWR sky130_fd_sc_hd__tapvpwrvgnd_1
X_4320_ _7066_/Q _4305_/B _4205_/A VGND VGND VPWR VPWR _4362_/B sky130_fd_sc_hd__o21a_2
XFILLER_114_725 VGND VGND VPWR VPWR sky130_fd_sc_hd__decap_3
XFILLER_99_447 VGND VGND VPWR VPWR sky130_fd_sc_hd__fill_1
X_4251_ _7016_/Q _4356_/A2 _4267_/A2 _7133_/Q _4250_/X VGND VGND VPWR VPWR _4251_/X
+ sky130_fd_sc_hd__a221o_2
XFILLER_87_609 VGND VGND VPWR VPWR sky130_fd_sc_hd__decap_3
XPHY_EDGE_ROW_91_Right_91 VGND VGND VPWR VPWR sky130_fd_sc_hd__decap_3
XFILLER_113_257 VGND VGND VPWR VPWR sky130_fd_sc_hd__decap_3
XFILLER_86_108 VGND VGND VPWR VPWR sky130_fd_sc_hd__decap_3
XFILLER_101_419 VGND VGND VPWR VPWR sky130_fd_sc_hd__decap_3
X_4182_ _7136_/Q _4267_/A2 _4180_/X _4181_/X VGND VGND VPWR VPWR _4182_/X sky130_fd_sc_hd__a211o_2
XFILLER_95_620 VGND VGND VPWR VPWR sky130_fd_sc_hd__decap_3
XFILLER_67_322 VGND VGND VPWR VPWR sky130_fd_sc_hd__decap_3
XFILLER_79_182 VGND VGND VPWR VPWR sky130_fd_sc_hd__fill_1
XFILLER_95_653 VGND VGND VPWR VPWR sky130_fd_sc_hd__decap_3
XFILLER_94_141 VGND VGND VPWR VPWR sky130_fd_sc_hd__decap_3
XFILLER_95_697 VGND VGND VPWR VPWR sky130_fd_sc_hd__decap_3
XFILLER_94_174 VGND VGND VPWR VPWR sky130_fd_sc_hd__fill_1
XFILLER_36_731 VGND VGND VPWR VPWR sky130_fd_sc_hd__decap_3
XTAP_TAPCELL_ROW_38_759 VGND VPWR sky130_fd_sc_hd__tapvpwrvgnd_1
XFILLER_63_561 VGND VGND VPWR VPWR sky130_fd_sc_hd__decap_3
XFILLER_35_252 VGND VGND VPWR VPWR sky130_fd_sc_hd__decap_3
XFILLER_51_712 VGND VGND VPWR VPWR sky130_fd_sc_hd__decap_3
XFILLER_50_200 VGND VGND VPWR VPWR sky130_fd_sc_hd__decap_3
XFILLER_35_274 VGND VGND VPWR VPWR sky130_fd_sc_hd__decap_3
X_6823_ clkload8/A _6823_/D VGND VGND VPWR VPWR _6823_/Q sky130_fd_sc_hd__dfxtp_2
XFILLER_90_380 VGND VGND VPWR VPWR sky130_fd_sc_hd__decap_3
XFILLER_50_222 VGND VGND VPWR VPWR sky130_fd_sc_hd__decap_3
XFILLER_35_296 VGND VGND VPWR VPWR sky130_fd_sc_hd__decap_3
XFILLER_23_447 VGND VGND VPWR VPWR sky130_fd_sc_hd__fill_1
XFILLER_23_458 VGND VGND VPWR VPWR sky130_fd_sc_hd__decap_3
X_6754_ _6960_/CLK _6754_/D VGND VGND VPWR VPWR _6754_/Q sky130_fd_sc_hd__dfxtp_2
XFILLER_11_609 VGND VGND VPWR VPWR sky130_fd_sc_hd__decap_3
X_3966_ _7357_/Q hold982/X _3966_/S VGND VGND VPWR VPWR _7357_/D sky130_fd_sc_hd__mux2_2
XFILLER_50_277 VGND VGND VPWR VPWR sky130_fd_sc_hd__decap_3
X_5705_ hold905/X _5712_/S _4270_/Y VGND VGND VPWR VPWR _6702_/D sky130_fd_sc_hd__a21bo_2
X_6685_ _6685_/A VGND VGND VPWR VPWR _6685_/Y sky130_fd_sc_hd__inv_2
X_3897_ hold952/X _5104_/A _3896_/Y VGND VGND VPWR VPWR _7382_/D sky130_fd_sc_hd__a21bo_2
XTAP_TAPCELL_ROW_98_1536 VGND VPWR sky130_fd_sc_hd__tapvpwrvgnd_1
XTAP_TAPCELL_ROW_98_1547 VGND VPWR sky130_fd_sc_hd__tapvpwrvgnd_1
X_5567_ hold941/X _4909_/A _4870_/Y VGND VGND VPWR VPWR _7050_/D sky130_fd_sc_hd__a21o_2
XFILLER_117_541 VGND VGND VPWR VPWR sky130_fd_sc_hd__decap_3
XFILLER_105_703 VGND VGND VPWR VPWR sky130_fd_sc_hd__decap_3
X_7306_ _7374_/CLK _7306_/D _6586_/Y VGND VGND VPWR VPWR _7306_/Q sky130_fd_sc_hd__dfrtp_2
XFILLER_117_585 VGND VGND VPWR VPWR sky130_fd_sc_hd__decap_3
X_7237_ _7374_/CLK _7237_/D _6517_/Y VGND VGND VPWR VPWR _7237_/Q sky130_fd_sc_hd__dfrtp_2
X_4449_ _4403_/A _4411_/B _4448_/X VGND VGND VPWR VPWR _4761_/C sky130_fd_sc_hd__a21oi_2
XFILLER_104_246 VGND VGND VPWR VPWR sky130_fd_sc_hd__decap_3
XFILLER_77_108 VGND VGND VPWR VPWR sky130_fd_sc_hd__decap_3
XFILLER_120_728 VGND VGND VPWR VPWR sky130_fd_sc_hd__decap_3
XFILLER_77_119 VGND VGND VPWR VPWR sky130_fd_sc_hd__decap_3
X_7168_ _7360_/CLK _7168_/D _6448_/Y VGND VGND VPWR VPWR _7168_/Q sky130_fd_sc_hd__dfrtp_2
XFILLER_98_480 VGND VGND VPWR VPWR sky130_fd_sc_hd__decap_3
XFILLER_86_631 VGND VGND VPWR VPWR sky130_fd_sc_hd__decap_3
XFILLER_100_430 VGND VGND VPWR VPWR sky130_fd_sc_hd__decap_3
XFILLER_58_355 VGND VGND VPWR VPWR sky130_fd_sc_hd__decap_3
XFILLER_19_709 VGND VGND VPWR VPWR sky130_fd_sc_hd__decap_3
X_7099_ _7354_/CLK _7099_/D _6379_/Y VGND VGND VPWR VPWR _7099_/Q sky130_fd_sc_hd__dfrtp_2
XFILLER_100_452 VGND VGND VPWR VPWR sky130_fd_sc_hd__decap_3
XFILLER_86_675 VGND VGND VPWR VPWR sky130_fd_sc_hd__decap_3
XFILLER_85_152 VGND VGND VPWR VPWR sky130_fd_sc_hd__decap_3
XFILLER_58_377 VGND VGND VPWR VPWR sky130_fd_sc_hd__fill_1
XFILLER_37_34 VGND VGND VPWR VPWR sky130_fd_sc_hd__decap_3
XFILLER_18_208 VGND VGND VPWR VPWR sky130_fd_sc_hd__decap_3
XTAP_TAPCELL_ROW_107_1654 VGND VPWR sky130_fd_sc_hd__tapvpwrvgnd_1
XFILLER_26_241 VGND VGND VPWR VPWR sky130_fd_sc_hd__fill_1
XFILLER_42_701 VGND VGND VPWR VPWR sky130_fd_sc_hd__decap_3
XFILLER_42_734 VGND VGND VPWR VPWR sky130_fd_sc_hd__fill_1
XFILLER_81_391 VGND VGND VPWR VPWR sky130_fd_sc_hd__fill_1
XTAP_TAPCELL_ROW_120_1821 VGND VPWR sky130_fd_sc_hd__tapvpwrvgnd_1
XTAP_TAPCELL_ROW_120_1832 VGND VPWR sky130_fd_sc_hd__tapvpwrvgnd_1
XFILLER_41_266 VGND VGND VPWR VPWR sky130_fd_sc_hd__decap_3
XFILLER_22_480 VGND VGND VPWR VPWR sky130_fd_sc_hd__decap_3
XFILLER_10_631 VGND VGND VPWR VPWR sky130_fd_sc_hd__decap_3
XFILLER_6_613 VGND VGND VPWR VPWR sky130_fd_sc_hd__decap_3
XFILLER_10_675 VGND VGND VPWR VPWR sky130_fd_sc_hd__decap_3
XTAP_TAPCELL_ROW_58_1019 VGND VPWR sky130_fd_sc_hd__tapvpwrvgnd_1
XFILLER_6_657 VGND VGND VPWR VPWR sky130_fd_sc_hd__decap_3
XFILLER_108_563 VGND VGND VPWR VPWR sky130_fd_sc_hd__decap_3
XFILLER_5_167 VGND VGND VPWR VPWR sky130_fd_sc_hd__fill_1
XFILLER_123_500 VGND VGND VPWR VPWR sky130_fd_sc_hd__decap_3
XFILLER_123_522 VGND VGND VPWR VPWR sky130_fd_sc_hd__fill_2
XFILLER_123_533 VGND VGND VPWR VPWR sky130_fd_sc_hd__decap_3
XFILLER_69_609 VGND VGND VPWR VPWR sky130_fd_sc_hd__decap_3
XFILLER_111_706 VGND VGND VPWR VPWR sky130_fd_sc_hd__decap_3
XFILLER_78_63 VGND VGND VPWR VPWR sky130_fd_sc_hd__decap_3
XFILLER_78_85 VGND VGND VPWR VPWR sky130_fd_sc_hd__decap_3
XFILLER_77_620 VGND VGND VPWR VPWR sky130_fd_sc_hd__decap_3
XFILLER_49_311 VGND VGND VPWR VPWR sky130_fd_sc_hd__decap_3
XFILLER_89_491 VGND VGND VPWR VPWR sky130_fd_sc_hd__fill_2
XFILLER_77_653 VGND VGND VPWR VPWR sky130_fd_sc_hd__decap_3
XFILLER_49_344 VGND VGND VPWR VPWR sky130_fd_sc_hd__decap_3
XFILLER_92_601 VGND VGND VPWR VPWR sky130_fd_sc_hd__decap_3
XFILLER_76_152 VGND VGND VPWR VPWR sky130_fd_sc_hd__decap_3
XFILLER_77_697 VGND VGND VPWR VPWR sky130_fd_sc_hd__decap_3
XFILLER_37_528 VGND VGND VPWR VPWR sky130_fd_sc_hd__decap_3
XFILLER_76_174 VGND VGND VPWR VPWR sky130_fd_sc_hd__fill_1
XFILLER_92_634 VGND VGND VPWR VPWR sky130_fd_sc_hd__decap_3
XFILLER_94_73 VGND VGND VPWR VPWR sky130_fd_sc_hd__fill_2
XFILLER_92_645 VGND VGND VPWR VPWR sky130_fd_sc_hd__decap_3
XFILLER_18_731 VGND VGND VPWR VPWR sky130_fd_sc_hd__decap_3
XTAP_TAPCELL_ROW_69_1159 VGND VPWR sky130_fd_sc_hd__tapvpwrvgnd_1
XFILLER_92_678 VGND VGND VPWR VPWR sky130_fd_sc_hd__decap_3
XFILLER_17_252 VGND VGND VPWR VPWR sky130_fd_sc_hd__fill_1
XTAP_TAPCELL_ROW_35_718 VGND VPWR sky130_fd_sc_hd__tapvpwrvgnd_1
XFILLER_33_712 VGND VGND VPWR VPWR sky130_fd_sc_hd__decap_3
XFILLER_32_200 VGND VGND VPWR VPWR sky130_fd_sc_hd__decap_3
XFILLER_17_274 VGND VGND VPWR VPWR sky130_fd_sc_hd__fill_1
XFILLER_72_380 VGND VGND VPWR VPWR sky130_fd_sc_hd__decap_3
XTAP_TAPCELL_ROW_82_1337 VGND VPWR sky130_fd_sc_hd__tapvpwrvgnd_1
XFILLER_32_222 VGND VGND VPWR VPWR sky130_fd_sc_hd__decap_3
XFILLER_60_542 VGND VGND VPWR VPWR sky130_fd_sc_hd__fill_2
X_3820_ _6927_/Q _3926_/A2 _3917_/A2 _6701_/Q VGND VGND VPWR VPWR _3820_/X sky130_fd_sc_hd__a22o_2
XTAP_TAPCELL_ROW_15_464 VGND VPWR sky130_fd_sc_hd__tapvpwrvgnd_1
XFILLER_60_586 VGND VGND VPWR VPWR sky130_fd_sc_hd__fill_2
XFILLER_32_288 VGND VGND VPWR VPWR sky130_fd_sc_hd__decap_3
X_3751_ _6935_/Q _3898_/A2 _3759_/B1 _6887_/Q VGND VGND VPWR VPWR _3751_/X sky130_fd_sc_hd__a22o_2
XFILLER_9_440 VGND VGND VPWR VPWR sky130_fd_sc_hd__decap_3
X_6470_ _6632_/A VGND VGND VPWR VPWR _6470_/Y sky130_fd_sc_hd__inv_2
XFILLER_71_3 VGND VGND VPWR VPWR sky130_fd_sc_hd__decap_3
X_3682_ _3682_/A _3682_/B VGND VGND VPWR VPWR _3682_/Y sky130_fd_sc_hd__nand2_2
XFILLER_118_338 VGND VGND VPWR VPWR sky130_fd_sc_hd__decap_3
X_5421_ _5421_/A0 _5135_/X _5429_/S VGND VGND VPWR VPWR _7123_/D sky130_fd_sc_hd__mux2_2
X_5352_ _5352_/A0 _5135_/X _7412_/A VGND VGND VPWR VPWR _7155_/D sky130_fd_sc_hd__mux2_2
XFILLER_114_511 VGND VGND VPWR VPWR sky130_fd_sc_hd__decap_3
XFILLER_114_533 VGND VGND VPWR VPWR sky130_fd_sc_hd__decap_3
X_4303_ _7320_/Q _3996_/S _4341_/B1 _7128_/Q _4302_/X VGND VGND VPWR VPWR _4303_/X
+ sky130_fd_sc_hd__a221o_2
XTAP_TAPCELL_ROW_93_1477 VGND VPWR sky130_fd_sc_hd__tapvpwrvgnd_1
X_5283_ _3600_/A _4788_/A _5238_/X _5283_/B2 VGND VGND VPWR VPWR _7188_/D sky130_fd_sc_hd__a22o_2
XFILLER_114_566 VGND VGND VPWR VPWR sky130_fd_sc_hd__decap_3
XFILLER_99_277 VGND VGND VPWR VPWR sky130_fd_sc_hd__decap_3
X_7022_ _7399_/CLK _7022_/D _6302_/Y VGND VGND VPWR VPWR _7022_/Q sky130_fd_sc_hd__dfrtp_2
XFILLER_87_428 VGND VGND VPWR VPWR sky130_fd_sc_hd__decap_3
XFILLER_102_728 VGND VGND VPWR VPWR sky130_fd_sc_hd__decap_3
XFILLER_101_205 VGND VGND VPWR VPWR sky130_fd_sc_hd__decap_3
X_4234_ _7355_/Q _4346_/B1 _4233_/X _4248_/A VGND VGND VPWR VPWR _4234_/X sky130_fd_sc_hd__a211o_2
XFILLER_68_631 VGND VGND VPWR VPWR sky130_fd_sc_hd__decap_3
XFILLER_4_93 VGND VGND VPWR VPWR sky130_fd_sc_hd__decap_3
X_4165_ _7018_/Q _4422_/A2 _4434_/B1 _7137_/Q _4164_/X VGND VGND VPWR VPWR _4165_/X
+ sky130_fd_sc_hd__a221o_2
XFILLER_68_675 VGND VGND VPWR VPWR sky130_fd_sc_hd__decap_3
XFILLER_28_517 VGND VGND VPWR VPWR sky130_fd_sc_hd__fill_1
XFILLER_83_612 VGND VGND VPWR VPWR sky130_fd_sc_hd__decap_3
XFILLER_67_163 VGND VGND VPWR VPWR sky130_fd_sc_hd__decap_3
XFILLER_83_623 VGND VGND VPWR VPWR sky130_fd_sc_hd__decap_3
XFILLER_82_100 VGND VGND VPWR VPWR sky130_fd_sc_hd__decap_3
XFILLER_55_325 VGND VGND VPWR VPWR sky130_fd_sc_hd__fill_1
XFILLER_28_539 VGND VGND VPWR VPWR sky130_fd_sc_hd__fill_2
X_4096_ _4096_/A _4096_/B VGND VGND VPWR VPWR _4633_/A sky130_fd_sc_hd__nand2_2
XFILLER_82_122 VGND VGND VPWR VPWR sky130_fd_sc_hd__decap_3
XFILLER_83_656 VGND VGND VPWR VPWR sky130_fd_sc_hd__decap_3
XFILLER_82_144 VGND VGND VPWR VPWR sky130_fd_sc_hd__decap_3
XFILLER_82_166 VGND VGND VPWR VPWR sky130_fd_sc_hd__decap_3
XFILLER_24_701 VGND VGND VPWR VPWR sky130_fd_sc_hd__decap_3
XFILLER_82_188 VGND VGND VPWR VPWR sky130_fd_sc_hd__decap_3
XFILLER_24_734 VGND VGND VPWR VPWR sky130_fd_sc_hd__fill_1
XFILLER_63_391 VGND VGND VPWR VPWR sky130_fd_sc_hd__fill_1
X_6806_ _6965_/CLK _6806_/D VGND VGND VPWR VPWR _6806_/Q sky130_fd_sc_hd__dfxtp_2
Xplace380 _5104_/A VGND VGND VPWR VPWR _4791_/A1 sky130_fd_sc_hd__buf_2
XFILLER_51_564 VGND VGND VPWR VPWR sky130_fd_sc_hd__decap_3
Xplace391 _4671_/B VGND VGND VPWR VPWR _4690_/B sky130_fd_sc_hd__buf_2
X_4998_ _4998_/A0 _4997_/X _5028_/S VGND VGND VPWR VPWR _7262_/D sky130_fd_sc_hd__mux2_2
XFILLER_11_417 VGND VGND VPWR VPWR sky130_fd_sc_hd__decap_3
X_3949_ _7365_/Q _4493_/A0 _3956_/S VGND VGND VPWR VPWR _7365_/D sky130_fd_sc_hd__mux2_2
X_6737_ clkload9/A _6737_/D VGND VGND VPWR VPWR _6737_/Q sky130_fd_sc_hd__dfxtp_2
XTAP_TAPCELL_ROW_102_1595 VGND VPWR sky130_fd_sc_hd__tapvpwrvgnd_1
X_6668_ _6672_/A VGND VGND VPWR VPWR _6668_/Y sky130_fd_sc_hd__inv_2
XFILLER_109_327 VGND VGND VPWR VPWR sky130_fd_sc_hd__decap_3
XFILLER_99_29 VGND VGND VPWR VPWR sky130_fd_sc_hd__fill_2
XFILLER_109_349 VGND VGND VPWR VPWR sky130_fd_sc_hd__decap_3
X_5619_ _5619_/A _5633_/B VGND VGND VPWR VPWR _7018_/D sky130_fd_sc_hd__or2_2
X_6599_ _6635_/A VGND VGND VPWR VPWR _6599_/Y sky130_fd_sc_hd__inv_2
XFILLER_117_360 VGND VGND VPWR VPWR sky130_fd_sc_hd__decap_3
XFILLER_3_638 VGND VGND VPWR VPWR sky130_fd_sc_hd__decap_3
XFILLER_117_393 VGND VGND VPWR VPWR sky130_fd_sc_hd__decap_3
XFILLER_105_555 VGND VGND VPWR VPWR sky130_fd_sc_hd__decap_3
XFILLER_105_588 VGND VGND VPWR VPWR sky130_fd_sc_hd__decap_3
XFILLER_59_620 VGND VGND VPWR VPWR sky130_fd_sc_hd__decap_3
XFILLER_120_525 VGND VGND VPWR VPWR sky130_fd_sc_hd__decap_3
XFILLER_120_536 VGND VGND VPWR VPWR sky130_fd_sc_hd__decap_3
XFILLER_59_653 VGND VGND VPWR VPWR sky130_fd_sc_hd__decap_3
XFILLER_120_569 VGND VGND VPWR VPWR sky130_fd_sc_hd__decap_3
XFILLER_58_141 VGND VGND VPWR VPWR sky130_fd_sc_hd__decap_3
XFILLER_74_601 VGND VGND VPWR VPWR sky130_fd_sc_hd__decap_3
XFILLER_86_472 VGND VGND VPWR VPWR sky130_fd_sc_hd__decap_3
XFILLER_59_697 VGND VGND VPWR VPWR sky130_fd_sc_hd__decap_3
XFILLER_74_634 VGND VGND VPWR VPWR sky130_fd_sc_hd__decap_3
XFILLER_100_271 VGND VGND VPWR VPWR sky130_fd_sc_hd__decap_3
XFILLER_86_494 VGND VGND VPWR VPWR sky130_fd_sc_hd__decap_3
XFILLER_58_185 VGND VGND VPWR VPWR sky130_fd_sc_hd__decap_3
XFILLER_0_29 VGND VGND VPWR VPWR sky130_fd_sc_hd__fill_1
XFILLER_74_645 VGND VGND VPWR VPWR sky130_fd_sc_hd__decap_3
XFILLER_46_336 VGND VGND VPWR VPWR sky130_fd_sc_hd__decap_3
XFILLER_74_678 VGND VGND VPWR VPWR sky130_fd_sc_hd__decap_3
XFILLER_104_83 VGND VGND VPWR VPWR sky130_fd_sc_hd__fill_1
XFILLER_73_166 VGND VGND VPWR VPWR sky130_fd_sc_hd__fill_2
XFILLER_27_561 VGND VGND VPWR VPWR sky130_fd_sc_hd__decap_3
XFILLER_27_572 VGND VGND VPWR VPWR sky130_fd_sc_hd__decap_3
XFILLER_15_712 VGND VGND VPWR VPWR sky130_fd_sc_hd__decap_3
XFILLER_73_188 VGND VGND VPWR VPWR sky130_fd_sc_hd__decap_3
XFILLER_64_76 VGND VGND VPWR VPWR sky130_fd_sc_hd__decap_3
XFILLER_14_200 VGND VGND VPWR VPWR sky130_fd_sc_hd__fill_1
XPHY_EDGE_ROW_14_Left_138 VGND VGND VPWR VPWR sky130_fd_sc_hd__decap_3
XFILLER_42_531 VGND VGND VPWR VPWR sky130_fd_sc_hd__fill_1
XFILLER_14_233 VGND VGND VPWR VPWR sky130_fd_sc_hd__decap_3
XFILLER_30_704 VGND VGND VPWR VPWR sky130_fd_sc_hd__decap_3
XFILLER_120_71 VGND VGND VPWR VPWR sky130_fd_sc_hd__decap_3
XTAP_TAPCELL_ROW_12_423 VGND VPWR sky130_fd_sc_hd__tapvpwrvgnd_1
Xfanout70 _6278_/A VGND VGND VPWR VPWR _6553_/A sky130_fd_sc_hd__clkdlybuf4s25_1
XFILLER_80_97 VGND VGND VPWR VPWR sky130_fd_sc_hd__decap_3
XTAP_TAPCELL_ROW_40_787 VGND VPWR sky130_fd_sc_hd__tapvpwrvgnd_1
XFILLER_6_421 VGND VGND VPWR VPWR sky130_fd_sc_hd__decap_3
XPHY_EDGE_ROW_108_Right_108 VGND VGND VPWR VPWR sky130_fd_sc_hd__decap_3
XPHY_EDGE_ROW_23_Left_147 VGND VGND VPWR VPWR sky130_fd_sc_hd__decap_3
XFILLER_108_382 VGND VGND VPWR VPWR sky130_fd_sc_hd__decap_3
XFILLER_97_715 VGND VGND VPWR VPWR sky130_fd_sc_hd__decap_3
XFILLER_2_660 VGND VGND VPWR VPWR sky130_fd_sc_hd__decap_3
XFILLER_96_214 VGND VGND VPWR VPWR sky130_fd_sc_hd__decap_3
XFILLER_123_374 VGND VGND VPWR VPWR sky130_fd_sc_hd__decap_3
XFILLER_69_439 VGND VGND VPWR VPWR sky130_fd_sc_hd__decap_3
XFILLER_111_525 VGND VGND VPWR VPWR sky130_fd_sc_hd__decap_3
XFILLER_123_396 VGND VGND VPWR VPWR sky130_fd_sc_hd__decap_3
XFILLER_2_693 VGND VGND VPWR VPWR sky130_fd_sc_hd__decap_3
XFILLER_111_558 VGND VGND VPWR VPWR sky130_fd_sc_hd__fill_2
XFILLER_84_409 VGND VGND VPWR VPWR sky130_fd_sc_hd__decap_3
XFILLER_77_461 VGND VGND VPWR VPWR sky130_fd_sc_hd__fill_1
XFILLER_65_601 VGND VGND VPWR VPWR sky130_fd_sc_hd__decap_3
XFILLER_65_623 VGND VGND VPWR VPWR sky130_fd_sc_hd__decap_3
XFILLER_64_100 VGND VGND VPWR VPWR sky130_fd_sc_hd__fill_2
XFILLER_77_494 VGND VGND VPWR VPWR sky130_fd_sc_hd__decap_3
XFILLER_37_325 VGND VGND VPWR VPWR sky130_fd_sc_hd__decap_3
XFILLER_65_656 VGND VGND VPWR VPWR sky130_fd_sc_hd__decap_3
XFILLER_37_358 VGND VGND VPWR VPWR sky130_fd_sc_hd__decap_3
XFILLER_92_453 VGND VGND VPWR VPWR sky130_fd_sc_hd__decap_3
XFILLER_80_604 VGND VGND VPWR VPWR sky130_fd_sc_hd__decap_3
XFILLER_64_155 VGND VGND VPWR VPWR sky130_fd_sc_hd__decap_3
XPHY_EDGE_ROW_32_Left_156 VGND VGND VPWR VPWR sky130_fd_sc_hd__decap_3
XTAP_TAPCELL_ROW_48_887 VGND VPWR sky130_fd_sc_hd__tapvpwrvgnd_1
XFILLER_64_177 VGND VGND VPWR VPWR sky130_fd_sc_hd__decap_3
XFILLER_80_637 VGND VGND VPWR VPWR sky130_fd_sc_hd__decap_3
XFILLER_18_572 VGND VGND VPWR VPWR sky130_fd_sc_hd__decap_3
X_4921_ _4968_/A _4383_/C _4201_/X VGND VGND VPWR VPWR _4937_/B sky130_fd_sc_hd__a21bo_2
XFILLER_64_188 VGND VGND VPWR VPWR sky130_fd_sc_hd__decap_3
XFILLER_80_648 VGND VGND VPWR VPWR sky130_fd_sc_hd__decap_3
XFILLER_33_520 VGND VGND VPWR VPWR sky130_fd_sc_hd__decap_3
X_4852_ _4852_/A _5057_/A VGND VGND VPWR VPWR _5101_/A sky130_fd_sc_hd__and2_2
XFILLER_60_350 VGND VGND VPWR VPWR sky130_fd_sc_hd__decap_3
XFILLER_33_564 VGND VGND VPWR VPWR sky130_fd_sc_hd__decap_3
XFILLER_33_575 VGND VGND VPWR VPWR sky130_fd_sc_hd__decap_3
XFILLER_21_715 VGND VGND VPWR VPWR sky130_fd_sc_hd__decap_3
X_3803_ _6816_/Q _3891_/A2 _3878_/B1 _6821_/Q VGND VGND VPWR VPWR _3803_/X sky130_fd_sc_hd__a22o_2
XFILLER_20_214 VGND VGND VPWR VPWR sky130_fd_sc_hd__fill_2
X_4783_ _4646_/A _4646_/B _4827_/A VGND VGND VPWR VPWR _4829_/B sky130_fd_sc_hd__a21boi_2
XFILLER_119_603 VGND VGND VPWR VPWR sky130_fd_sc_hd__decap_3
X_6522_ _6680_/A VGND VGND VPWR VPWR _6522_/Y sky130_fd_sc_hd__inv_2
X_3734_ _3728_/Y _3730_/X _3732_/X _3733_/X VGND VGND VPWR VPWR _3734_/X sky130_fd_sc_hd__a22o_2
XFILLER_119_647 VGND VGND VPWR VPWR sky130_fd_sc_hd__decap_3
XFILLER_9_281 VGND VGND VPWR VPWR sky130_fd_sc_hd__decap_3
XTAP_TAPCELL_ROW_95_1506 VGND VPWR sky130_fd_sc_hd__tapvpwrvgnd_1
X_6453_ _6614_/A VGND VGND VPWR VPWR _6453_/Y sky130_fd_sc_hd__inv_2
X_3665_ _3665_/A _3665_/B VGND VGND VPWR VPWR _3665_/X sky130_fd_sc_hd__and2_4
XFILLER_118_157 VGND VGND VPWR VPWR sky130_fd_sc_hd__decap_3
XPHY_EDGE_ROW_41_Left_165 VGND VGND VPWR VPWR sky130_fd_sc_hd__decap_3
XFILLER_109_39 VGND VGND VPWR VPWR sky130_fd_sc_hd__decap_3
X_5404_ _5404_/A0 _5040_/X _5427_/S VGND VGND VPWR VPWR _7131_/D sky130_fd_sc_hd__mux2_2
X_6384_ _6608_/A VGND VGND VPWR VPWR _6384_/Y sky130_fd_sc_hd__inv_2
X_3596_ _4295_/B _3607_/B VGND VGND VPWR VPWR _3598_/A sky130_fd_sc_hd__and2_2
XFILLER_88_704 VGND VGND VPWR VPWR sky130_fd_sc_hd__decap_3
XFILLER_0_608 VGND VGND VPWR VPWR sky130_fd_sc_hd__decap_3
XFILLER_114_374 VGND VGND VPWR VPWR sky130_fd_sc_hd__fill_1
XFILLER_87_214 VGND VGND VPWR VPWR sky130_fd_sc_hd__fill_1
X_5266_ _5266_/A0 _5011_/X _5278_/S VGND VGND VPWR VPWR _7197_/D sky130_fd_sc_hd__mux2_2
XFILLER_87_225 VGND VGND VPWR VPWR sky130_fd_sc_hd__decap_3
XFILLER_102_536 VGND VGND VPWR VPWR sky130_fd_sc_hd__decap_3
X_7005_ _7406_/CLK _7005_/D _6285_/Y VGND VGND VPWR VPWR _7005_/Q sky130_fd_sc_hd__dfrtp_2
X_4217_ _3469_/A _3469_/B _3449_/A _7015_/Q _6980_/Q VGND VGND VPWR VPWR _4217_/X
+ sky130_fd_sc_hd__o2111a_2
XFILLER_102_569 VGND VGND VPWR VPWR sky130_fd_sc_hd__decap_3
XFILLER_87_269 VGND VGND VPWR VPWR sky130_fd_sc_hd__decap_3
XFILLER_56_601 VGND VGND VPWR VPWR sky130_fd_sc_hd__decap_3
XFILLER_68_461 VGND VGND VPWR VPWR sky130_fd_sc_hd__fill_2
XFILLER_68_472 VGND VGND VPWR VPWR sky130_fd_sc_hd__decap_3
XFILLER_68_483 VGND VGND VPWR VPWR sky130_fd_sc_hd__decap_3
X_4148_ _7074_/Q _4265_/B _4145_/X _4147_/X VGND VGND VPWR VPWR _4205_/B sky130_fd_sc_hd__o22a_2
XFILLER_56_634 VGND VGND VPWR VPWR sky130_fd_sc_hd__decap_3
XFILLER_55_111 VGND VGND VPWR VPWR sky130_fd_sc_hd__fill_1
XFILLER_56_645 VGND VGND VPWR VPWR sky130_fd_sc_hd__decap_3
XFILLER_28_336 VGND VGND VPWR VPWR sky130_fd_sc_hd__decap_3
XPHY_EDGE_ROW_50_Left_174 VGND VGND VPWR VPWR sky130_fd_sc_hd__decap_3
XFILLER_83_464 VGND VGND VPWR VPWR sky130_fd_sc_hd__decap_3
XFILLER_71_604 VGND VGND VPWR VPWR sky130_fd_sc_hd__decap_3
XFILLER_56_678 VGND VGND VPWR VPWR sky130_fd_sc_hd__decap_3
X_4079_ _7403_/Q _4437_/B1 _4077_/X _4078_/X VGND VGND VPWR VPWR _4079_/X sky130_fd_sc_hd__a211o_2
XFILLER_43_306 VGND VGND VPWR VPWR sky130_fd_sc_hd__fill_1
XFILLER_71_626 VGND VGND VPWR VPWR sky130_fd_sc_hd__decap_3
XTAP_TAPCELL_ROW_104_1613 VGND VPWR sky130_fd_sc_hd__tapvpwrvgnd_1
XTAP_TAPCELL_ROW_104_1624 VGND VPWR sky130_fd_sc_hd__tapvpwrvgnd_1
XFILLER_71_659 VGND VGND VPWR VPWR sky130_fd_sc_hd__decap_3
XFILLER_36_380 VGND VGND VPWR VPWR sky130_fd_sc_hd__decap_3
XFILLER_24_531 VGND VGND VPWR VPWR sky130_fd_sc_hd__fill_1
XFILLER_70_147 VGND VGND VPWR VPWR sky130_fd_sc_hd__decap_3
XFILLER_34_46 VGND VGND VPWR VPWR sky130_fd_sc_hd__decap_3
XFILLER_12_704 VGND VGND VPWR VPWR sky130_fd_sc_hd__decap_3
XFILLER_51_361 VGND VGND VPWR VPWR sky130_fd_sc_hd__decap_3
XFILLER_24_575 VGND VGND VPWR VPWR sky130_fd_sc_hd__decap_3
XFILLER_11_236 VGND VGND VPWR VPWR sky130_fd_sc_hd__decap_3
XFILLER_8_719 VGND VGND VPWR VPWR sky130_fd_sc_hd__decap_3
Xclkload1 clkload1/A VGND VGND VPWR VPWR clkload1/X sky130_fd_sc_hd__clkbuf_16
XFILLER_109_124 VGND VGND VPWR VPWR sky130_fd_sc_hd__decap_3
XFILLER_119_3 VGND VGND VPWR VPWR sky130_fd_sc_hd__decap_3
XFILLER_3_413 VGND VGND VPWR VPWR sky130_fd_sc_hd__decap_3
XTAP_TAPCELL_ROW_115_1764 VGND VPWR sky130_fd_sc_hd__tapvpwrvgnd_1
XFILLER_3_446 VGND VGND VPWR VPWR sky130_fd_sc_hd__fill_2
XFILLER_79_715 VGND VGND VPWR VPWR sky130_fd_sc_hd__decap_3
XFILLER_59_32 VGND VGND VPWR VPWR sky130_fd_sc_hd__decap_3
XFILLER_3_479 VGND VGND VPWR VPWR sky130_fd_sc_hd__fill_1
XFILLER_78_203 VGND VGND VPWR VPWR sky130_fd_sc_hd__decap_3
XFILLER_78_236 VGND VGND VPWR VPWR sky130_fd_sc_hd__decap_3
XFILLER_94_707 VGND VGND VPWR VPWR sky130_fd_sc_hd__decap_3
XFILLER_93_206 VGND VGND VPWR VPWR sky130_fd_sc_hd__decap_3
XFILLER_47_601 VGND VGND VPWR VPWR sky130_fd_sc_hd__decap_3
XFILLER_120_377 VGND VGND VPWR VPWR sky130_fd_sc_hd__decap_3
XFILLER_115_60 VGND VGND VPWR VPWR sky130_fd_sc_hd__decap_3
XFILLER_93_228 VGND VGND VPWR VPWR sky130_fd_sc_hd__decap_3
XFILLER_47_623 VGND VGND VPWR VPWR sky130_fd_sc_hd__decap_3
XFILLER_86_280 VGND VGND VPWR VPWR sky130_fd_sc_hd__decap_3
XFILLER_46_111 VGND VGND VPWR VPWR sky130_fd_sc_hd__decap_3
XFILLER_115_93 VGND VGND VPWR VPWR sky130_fd_sc_hd__decap_3
XFILLER_101_591 VGND VGND VPWR VPWR sky130_fd_sc_hd__decap_3
XFILLER_47_656 VGND VGND VPWR VPWR sky130_fd_sc_hd__decap_3
XFILLER_19_347 VGND VGND VPWR VPWR sky130_fd_sc_hd__fill_2
XFILLER_46_144 VGND VGND VPWR VPWR sky130_fd_sc_hd__fill_1
XFILLER_34_306 VGND VGND VPWR VPWR sky130_fd_sc_hd__fill_2
XFILLER_62_626 VGND VGND VPWR VPWR sky130_fd_sc_hd__decap_3
XTAP_TAPCELL_ROW_66_1129 VGND VPWR sky130_fd_sc_hd__tapvpwrvgnd_1
XFILLER_46_188 VGND VGND VPWR VPWR sky130_fd_sc_hd__decap_3
XFILLER_62_648 VGND VGND VPWR VPWR sky130_fd_sc_hd__decap_3
XTAP_TAPCELL_ROW_45_846 VGND VPWR sky130_fd_sc_hd__tapvpwrvgnd_1
XFILLER_15_520 VGND VGND VPWR VPWR sky130_fd_sc_hd__decap_3
XTAP_TAPCELL_ROW_45_857 VGND VPWR sky130_fd_sc_hd__tapvpwrvgnd_1
XFILLER_61_147 VGND VGND VPWR VPWR sky130_fd_sc_hd__decap_3
XFILLER_15_553 VGND VGND VPWR VPWR sky130_fd_sc_hd__decap_3
XFILLER_61_169 VGND VGND VPWR VPWR sky130_fd_sc_hd__decap_3
XFILLER_15_564 VGND VGND VPWR VPWR sky130_fd_sc_hd__decap_3
XFILLER_42_361 VGND VGND VPWR VPWR sky130_fd_sc_hd__decap_3
XFILLER_70_681 VGND VGND VPWR VPWR sky130_fd_sc_hd__decap_3
XFILLER_42_372 VGND VGND VPWR VPWR sky130_fd_sc_hd__decap_3
XFILLER_15_597 VGND VGND VPWR VPWR sky130_fd_sc_hd__decap_3
XTAP_TAPCELL_ROW_25_592 VGND VPWR sky130_fd_sc_hd__tapvpwrvgnd_1
XFILLER_30_556 VGND VGND VPWR VPWR sky130_fd_sc_hd__decap_3
XFILLER_30_578 VGND VGND VPWR VPWR sky130_fd_sc_hd__decap_3
XFILLER_30_589 VGND VGND VPWR VPWR sky130_fd_sc_hd__decap_3
XFILLER_10_280 VGND VGND VPWR VPWR sky130_fd_sc_hd__decap_3
Xhold708 _6790_/Q VGND VGND VPWR VPWR _6790_/D sky130_fd_sc_hd__dlygate4sd3_1
XFILLER_116_628 VGND VGND VPWR VPWR sky130_fd_sc_hd__decap_3
Xhold719 _6911_/Q VGND VGND VPWR VPWR _6911_/D sky130_fd_sc_hd__dlygate4sd3_1
XFILLER_115_105 VGND VGND VPWR VPWR sky130_fd_sc_hd__decap_3
XFILLER_109_691 VGND VGND VPWR VPWR sky130_fd_sc_hd__decap_3
XTAP_TAPCELL_ROW_77_1269 VGND VPWR sky130_fd_sc_hd__tapvpwrvgnd_1
XFILLER_6_295 VGND VGND VPWR VPWR sky130_fd_sc_hd__decap_3
XFILLER_115_149 VGND VGND VPWR VPWR sky130_fd_sc_hd__fill_1
XFILLER_108_190 VGND VGND VPWR VPWR sky130_fd_sc_hd__decap_3
XTAP_TAPCELL_ROW_90_1436 VGND VPWR sky130_fd_sc_hd__tapvpwrvgnd_1
X_5120_ _5120_/A _5120_/B VGND VGND VPWR VPWR _6984_/D sky130_fd_sc_hd__nor2_2
XFILLER_111_311 VGND VGND VPWR VPWR sky130_fd_sc_hd__decap_3
XFILLER_69_225 VGND VGND VPWR VPWR sky130_fd_sc_hd__decap_3
XFILLER_97_556 VGND VGND VPWR VPWR sky130_fd_sc_hd__decap_3
XFILLER_97_567 VGND VGND VPWR VPWR sky130_fd_sc_hd__decap_3
X_5051_ _5073_/A _5050_/X _5054_/A VGND VGND VPWR VPWR _5051_/X sky130_fd_sc_hd__a21o_2
XFILLER_85_718 VGND VGND VPWR VPWR sky130_fd_sc_hd__decap_3
XFILLER_85_729 VGND VGND VPWR VPWR sky130_fd_sc_hd__decap_3
XFILLER_38_601 VGND VGND VPWR VPWR sky130_fd_sc_hd__decap_3
XFILLER_84_217 VGND VGND VPWR VPWR sky130_fd_sc_hd__decap_3
XFILLER_111_388 VGND VGND VPWR VPWR sky130_fd_sc_hd__decap_3
XFILLER_111_399 VGND VGND VPWR VPWR sky130_fd_sc_hd__fill_1
XFILLER_38_634 VGND VGND VPWR VPWR sky130_fd_sc_hd__decap_3
XFILLER_65_431 VGND VGND VPWR VPWR sky130_fd_sc_hd__decap_3
XFILLER_38_645 VGND VGND VPWR VPWR sky130_fd_sc_hd__decap_3
XFILLER_38_678 VGND VGND VPWR VPWR sky130_fd_sc_hd__decap_3
XFILLER_92_250 VGND VGND VPWR VPWR sky130_fd_sc_hd__fill_2
XFILLER_65_464 VGND VGND VPWR VPWR sky130_fd_sc_hd__decap_3
XFILLER_53_615 VGND VGND VPWR VPWR sky130_fd_sc_hd__fill_1
XFILLER_53_626 VGND VGND VPWR VPWR sky130_fd_sc_hd__decap_3
XFILLER_25_317 VGND VGND VPWR VPWR sky130_fd_sc_hd__fill_2
XFILLER_1_94 VGND VGND VPWR VPWR sky130_fd_sc_hd__fill_1
XFILLER_92_283 VGND VGND VPWR VPWR sky130_fd_sc_hd__decap_3
XFILLER_111_18 VGND VGND VPWR VPWR sky130_fd_sc_hd__decap_3
XFILLER_53_659 VGND VGND VPWR VPWR sky130_fd_sc_hd__decap_3
XFILLER_52_147 VGND VGND VPWR VPWR sky130_fd_sc_hd__fill_1
XFILLER_18_391 VGND VGND VPWR VPWR sky130_fd_sc_hd__decap_3
X_4904_ _4903_/A _4904_/B VGND VGND VPWR VPWR _4904_/X sky130_fd_sc_hd__and2b_2
XFILLER_40_309 VGND VGND VPWR VPWR sky130_fd_sc_hd__decap_3
X_4835_ _4467_/B _3709_/X _4832_/X _4834_/Y VGND VGND VPWR VPWR _4835_/X sky130_fd_sc_hd__a31o_2
XFILLER_60_180 VGND VGND VPWR VPWR sky130_fd_sc_hd__decap_3
XFILLER_119_411 VGND VGND VPWR VPWR sky130_fd_sc_hd__fill_1
X_4766_ _4766_/A VGND VGND VPWR VPWR _4766_/Y sky130_fd_sc_hd__inv_2
XFILLER_21_589 VGND VGND VPWR VPWR sky130_fd_sc_hd__decap_3
XFILLER_119_444 VGND VGND VPWR VPWR sky130_fd_sc_hd__fill_1
X_6505_ _6638_/A VGND VGND VPWR VPWR _6505_/Y sky130_fd_sc_hd__inv_2
XFILLER_119_466 VGND VGND VPWR VPWR sky130_fd_sc_hd__decap_3
XFILLER_107_606 VGND VGND VPWR VPWR sky130_fd_sc_hd__decap_3
X_4697_ _5670_/A _6984_/Q _5670_/B VGND VGND VPWR VPWR _5120_/A sky130_fd_sc_hd__and3_2
XFILLER_107_617 VGND VGND VPWR VPWR sky130_fd_sc_hd__decap_3
XFILLER_119_499 VGND VGND VPWR VPWR sky130_fd_sc_hd__decap_3
X_6436_ _6630_/A VGND VGND VPWR VPWR _6436_/Y sky130_fd_sc_hd__inv_2
XFILLER_106_138 VGND VGND VPWR VPWR sky130_fd_sc_hd__fill_2
XFILLER_105_9 VGND VGND VPWR VPWR sky130_fd_sc_hd__decap_3
X_6367_ _6596_/A VGND VGND VPWR VPWR _6367_/Y sky130_fd_sc_hd__inv_2
XFILLER_115_650 VGND VGND VPWR VPWR sky130_fd_sc_hd__decap_3
X_3579_ _7220_/Q _4307_/A2 _3977_/S _7188_/Q VGND VGND VPWR VPWR _3579_/X sky130_fd_sc_hd__a22o_2
XFILLER_121_108 VGND VGND VPWR VPWR sky130_fd_sc_hd__decap_3
XFILLER_0_416 VGND VGND VPWR VPWR sky130_fd_sc_hd__decap_3
XFILLER_121_119 VGND VGND VPWR VPWR sky130_fd_sc_hd__decap_3
XFILLER_115_694 VGND VGND VPWR VPWR sky130_fd_sc_hd__decap_3
X_6298_ _6618_/A VGND VGND VPWR VPWR _6298_/Y sky130_fd_sc_hd__inv_2
XFILLER_114_182 VGND VGND VPWR VPWR sky130_fd_sc_hd__decap_3
XFILLER_102_322 VGND VGND VPWR VPWR sky130_fd_sc_hd__decap_3
XFILLER_0_449 VGND VGND VPWR VPWR sky130_fd_sc_hd__decap_3
XFILLER_88_556 VGND VGND VPWR VPWR sky130_fd_sc_hd__decap_3
XFILLER_114_193 VGND VGND VPWR VPWR sky130_fd_sc_hd__decap_3
XFILLER_76_707 VGND VGND VPWR VPWR sky130_fd_sc_hd__decap_3
XFILLER_48_409 VGND VGND VPWR VPWR sky130_fd_sc_hd__decap_3
X_5249_ _5249_/A0 _4878_/X _5258_/S VGND VGND VPWR VPWR _7205_/D sky130_fd_sc_hd__mux2_2
XFILLER_88_589 VGND VGND VPWR VPWR sky130_fd_sc_hd__decap_3
XFILLER_29_601 VGND VGND VPWR VPWR sky130_fd_sc_hd__decap_3
XFILLER_102_377 VGND VGND VPWR VPWR sky130_fd_sc_hd__decap_3
XTAP_TAPCELL_ROW_110_1694 VGND VPWR sky130_fd_sc_hd__tapvpwrvgnd_1
XFILLER_75_228 VGND VGND VPWR VPWR sky130_fd_sc_hd__fill_1
XFILLER_29_79 VGND VGND VPWR VPWR sky130_fd_sc_hd__decap_3
XFILLER_29_623 VGND VGND VPWR VPWR sky130_fd_sc_hd__decap_3
XFILLER_75_239 VGND VGND VPWR VPWR sky130_fd_sc_hd__decap_3
XFILLER_68_280 VGND VGND VPWR VPWR sky130_fd_sc_hd__decap_3
XFILLER_29_656 VGND VGND VPWR VPWR sky130_fd_sc_hd__decap_3
XFILLER_28_144 VGND VGND VPWR VPWR sky130_fd_sc_hd__decap_3
XFILLER_56_475 VGND VGND VPWR VPWR sky130_fd_sc_hd__fill_1
XFILLER_44_615 VGND VGND VPWR VPWR sky130_fd_sc_hd__decap_3
XFILLER_83_261 VGND VGND VPWR VPWR sky130_fd_sc_hd__decap_3
XFILLER_56_486 VGND VGND VPWR VPWR sky130_fd_sc_hd__decap_3
XFILLER_71_423 VGND VGND VPWR VPWR sky130_fd_sc_hd__decap_3
XFILLER_28_188 VGND VGND VPWR VPWR sky130_fd_sc_hd__decap_3
XFILLER_44_648 VGND VGND VPWR VPWR sky130_fd_sc_hd__decap_3
XFILLER_16_339 VGND VGND VPWR VPWR sky130_fd_sc_hd__decap_3
XFILLER_43_169 VGND VGND VPWR VPWR sky130_fd_sc_hd__fill_1
XTAP_TAPCELL_ROW_42_816 VGND VPWR sky130_fd_sc_hd__tapvpwrvgnd_1
XFILLER_52_681 VGND VGND VPWR VPWR sky130_fd_sc_hd__decap_3
XFILLER_12_556 VGND VGND VPWR VPWR sky130_fd_sc_hd__decap_3
XTAP_TAPCELL_ROW_61_1059 VGND VPWR sky130_fd_sc_hd__tapvpwrvgnd_1
XFILLER_8_516 VGND VGND VPWR VPWR sky130_fd_sc_hd__decap_3
XFILLER_61_55 VGND VGND VPWR VPWR sky130_fd_sc_hd__fill_1
XTAP_TAPCELL_ROW_22_551 VGND VPWR sky130_fd_sc_hd__tapvpwrvgnd_1
XFILLER_12_589 VGND VGND VPWR VPWR sky130_fd_sc_hd__decap_3
XFILLER_4_722 VGND VGND VPWR VPWR sky130_fd_sc_hd__decap_3
XFILLER_3_221 VGND VGND VPWR VPWR sky130_fd_sc_hd__decap_3
XFILLER_113_609 VGND VGND VPWR VPWR sky130_fd_sc_hd__decap_3
XFILLER_98_309 VGND VGND VPWR VPWR sky130_fd_sc_hd__decap_3
XFILLER_106_672 VGND VGND VPWR VPWR sky130_fd_sc_hd__decap_3
XFILLER_121_620 VGND VGND VPWR VPWR sky130_fd_sc_hd__decap_3
XFILLER_10_81 VGND VGND VPWR VPWR sky130_fd_sc_hd__decap_3
XFILLER_121_653 VGND VGND VPWR VPWR sky130_fd_sc_hd__decap_3
XFILLER_67_718 VGND VGND VPWR VPWR sky130_fd_sc_hd__decap_3
XFILLER_120_141 VGND VGND VPWR VPWR sky130_fd_sc_hd__fill_2
XFILLER_67_729 VGND VGND VPWR VPWR sky130_fd_sc_hd__decap_3
XTAP_TAPCELL_ROW_72_1199 VGND VPWR sky130_fd_sc_hd__tapvpwrvgnd_1
XFILLER_121_697 VGND VGND VPWR VPWR sky130_fd_sc_hd__decap_3
XFILLER_66_228 VGND VGND VPWR VPWR sky130_fd_sc_hd__decap_3
XFILLER_86_85 VGND VGND VPWR VPWR sky130_fd_sc_hd__decap_3
XFILLER_94_559 VGND VGND VPWR VPWR sky130_fd_sc_hd__decap_3
XFILLER_19_122 VGND VGND VPWR VPWR sky130_fd_sc_hd__fill_1
XFILLER_47_464 VGND VGND VPWR VPWR sky130_fd_sc_hd__decap_3
XFILLER_19_90 VGND VGND VPWR VPWR sky130_fd_sc_hd__decap_3
XFILLER_90_710 VGND VGND VPWR VPWR sky130_fd_sc_hd__decap_3
XFILLER_35_615 VGND VGND VPWR VPWR sky130_fd_sc_hd__fill_1
XFILLER_35_626 VGND VGND VPWR VPWR sky130_fd_sc_hd__decap_3
XFILLER_35_659 VGND VGND VPWR VPWR sky130_fd_sc_hd__decap_3
XFILLER_62_445 VGND VGND VPWR VPWR sky130_fd_sc_hd__decap_3
XFILLER_50_607 VGND VGND VPWR VPWR sky130_fd_sc_hd__decap_3
XFILLER_22_309 VGND VGND VPWR VPWR sky130_fd_sc_hd__decap_3
XPHY_EDGE_ROW_106_Left_230 VGND VGND VPWR VPWR sky130_fd_sc_hd__decap_3
XFILLER_42_191 VGND VGND VPWR VPWR sky130_fd_sc_hd__decap_3
XFILLER_30_331 VGND VGND VPWR VPWR sky130_fd_sc_hd__decap_3
X_4620_ _4620_/A _5003_/A _4987_/A _5032_/A VGND VGND VPWR VPWR _4624_/B sky130_fd_sc_hd__and4_4
XFILLER_30_386 VGND VGND VPWR VPWR sky130_fd_sc_hd__decap_3
X_3502_ _3502_/A _3502_/B _3485_/C VGND VGND VPWR VPWR _3502_/X sky130_fd_sc_hd__or3b_2
X_7270_ _7395_/CLK _7270_/D _6550_/Y VGND VGND VPWR VPWR _7270_/Q sky130_fd_sc_hd__dfrtp_2
XFILLER_7_582 VGND VGND VPWR VPWR sky130_fd_sc_hd__decap_3
X_4482_ _4482_/A0 _4548_/A _4486_/S VGND VGND VPWR VPWR _7338_/D sky130_fd_sc_hd__mux2_2
XFILLER_116_469 VGND VGND VPWR VPWR sky130_fd_sc_hd__decap_3
XFILLER_106_18 VGND VGND VPWR VPWR sky130_fd_sc_hd__decap_3
X_3364_ _3362_/X _5294_/B _3371_/A VGND VGND VPWR VPWR _3399_/B sky130_fd_sc_hd__a21boi_2
XFILLER_97_320 VGND VGND VPWR VPWR sky130_fd_sc_hd__fill_1
XFILLER_112_631 VGND VGND VPWR VPWR sky130_fd_sc_hd__decap_3
XFILLER_106_29 VGND VGND VPWR VPWR sky130_fd_sc_hd__decap_3
X_5103_ _5146_/B1 _5084_/B _5099_/X _5102_/X VGND VGND VPWR VPWR _5660_/C sky130_fd_sc_hd__a31oi_2
XFILLER_58_707 VGND VGND VPWR VPWR sky130_fd_sc_hd__decap_3
XFILLER_97_364 VGND VGND VPWR VPWR sky130_fd_sc_hd__decap_3
XFILLER_112_675 VGND VGND VPWR VPWR sky130_fd_sc_hd__decap_3
Xhold1205 _7396_/Q VGND VGND VPWR VPWR _3757_/A0 sky130_fd_sc_hd__dlygate4sd3_1
XFILLER_57_206 VGND VGND VPWR VPWR sky130_fd_sc_hd__decap_3
XFILLER_111_152 VGND VGND VPWR VPWR sky130_fd_sc_hd__decap_3
Xhold1216 _7220_/Q VGND VGND VPWR VPWR _5217_/A sky130_fd_sc_hd__dlygate4sd3_1
XFILLER_57_228 VGND VGND VPWR VPWR sky130_fd_sc_hd__decap_3
X_5034_ _4811_/C _5031_/X _5032_/Y _4969_/B _5033_/X VGND VGND VPWR VPWR _5658_/B
+ sky130_fd_sc_hd__a221o_2
XFILLER_85_559 VGND VGND VPWR VPWR sky130_fd_sc_hd__fill_1
XFILLER_122_17 VGND VGND VPWR VPWR sky130_fd_sc_hd__decap_3
XFILLER_38_464 VGND VGND VPWR VPWR sky130_fd_sc_hd__fill_2
XFILLER_26_604 VGND VGND VPWR VPWR sky130_fd_sc_hd__decap_3
XFILLER_93_570 VGND VGND VPWR VPWR sky130_fd_sc_hd__decap_3
XFILLER_81_721 VGND VGND VPWR VPWR sky130_fd_sc_hd__decap_3
XFILLER_26_637 VGND VGND VPWR VPWR sky130_fd_sc_hd__decap_3
XFILLER_81_732 VGND VGND VPWR VPWR sky130_fd_sc_hd__decap_3
XFILLER_26_648 VGND VGND VPWR VPWR sky130_fd_sc_hd__decap_3
XTAP_TAPCELL_ROW_0_257 VGND VPWR sky130_fd_sc_hd__tapvpwrvgnd_1
XFILLER_80_231 VGND VGND VPWR VPWR sky130_fd_sc_hd__decap_3
XTAP_TAPCELL_ROW_0_268 VGND VPWR sky130_fd_sc_hd__tapvpwrvgnd_1
X_6985_ _7386_/CLK _6985_/D _6265_/Y VGND VGND VPWR VPWR _6985_/Q sky130_fd_sc_hd__dfrtp_2
XFILLER_53_467 VGND VGND VPWR VPWR sky130_fd_sc_hd__decap_3
XFILLER_41_607 VGND VGND VPWR VPWR sky130_fd_sc_hd__decap_3
XFILLER_80_253 VGND VGND VPWR VPWR sky130_fd_sc_hd__decap_3
XFILLER_25_169 VGND VGND VPWR VPWR sky130_fd_sc_hd__fill_2
XFILLER_41_629 VGND VGND VPWR VPWR sky130_fd_sc_hd__decap_3
XFILLER_15_48 VGND VGND VPWR VPWR sky130_fd_sc_hd__decap_3
XFILLER_80_286 VGND VGND VPWR VPWR sky130_fd_sc_hd__decap_3
XFILLER_34_681 VGND VGND VPWR VPWR sky130_fd_sc_hd__decap_3
XFILLER_33_191 VGND VGND VPWR VPWR sky130_fd_sc_hd__decap_3
XFILLER_21_353 VGND VGND VPWR VPWR sky130_fd_sc_hd__decap_3
X_4818_ _7002_/Q _4834_/A VGND VGND VPWR VPWR _4818_/Y sky130_fd_sc_hd__nand2_2
X_4749_ _7006_/Q _4749_/B VGND VGND VPWR VPWR _4750_/C sky130_fd_sc_hd__nor2_2
XFILLER_119_274 VGND VGND VPWR VPWR sky130_fd_sc_hd__decap_3
XFILLER_103_6 VGND VGND VPWR VPWR sky130_fd_sc_hd__decap_3
XFILLER_107_469 VGND VGND VPWR VPWR sky130_fd_sc_hd__decap_3
X_6419_ _6610_/A VGND VGND VPWR VPWR _6419_/Y sky130_fd_sc_hd__inv_2
XFILLER_1_703 VGND VGND VPWR VPWR sky130_fd_sc_hd__decap_3
XTAP_TAPCELL_ROW_112_1723 VGND VPWR sky130_fd_sc_hd__tapvpwrvgnd_1
X_7399_ _7399_/CLK _7399_/D _6679_/Y VGND VGND VPWR VPWR _7399_/Q sky130_fd_sc_hd__dfrtp_2
XFILLER_1_714 VGND VGND VPWR VPWR sky130_fd_sc_hd__decap_3
XFILLER_103_620 VGND VGND VPWR VPWR sky130_fd_sc_hd__decap_3
XTAP_TAPCELL_ROW_8_368 VGND VPWR sky130_fd_sc_hd__tapvpwrvgnd_1
XFILLER_103_653 VGND VGND VPWR VPWR sky130_fd_sc_hd__decap_3
XFILLER_88_353 VGND VGND VPWR VPWR sky130_fd_sc_hd__decap_3
XFILLER_49_718 VGND VGND VPWR VPWR sky130_fd_sc_hd__decap_3
XFILLER_102_141 VGND VGND VPWR VPWR sky130_fd_sc_hd__decap_3
XFILLER_49_729 VGND VGND VPWR VPWR sky130_fd_sc_hd__decap_3
XFILLER_103_697 VGND VGND VPWR VPWR sky130_fd_sc_hd__decap_3
XFILLER_56_11 VGND VGND VPWR VPWR sky130_fd_sc_hd__fill_1
XFILLER_29_420 VGND VGND VPWR VPWR sky130_fd_sc_hd__decap_3
XFILLER_102_185 VGND VGND VPWR VPWR sky130_fd_sc_hd__decap_3
XFILLER_17_615 VGND VGND VPWR VPWR sky130_fd_sc_hd__fill_1
XFILLER_72_710 VGND VGND VPWR VPWR sky130_fd_sc_hd__decap_3
XFILLER_17_626 VGND VGND VPWR VPWR sky130_fd_sc_hd__decap_3
XFILLER_84_581 VGND VGND VPWR VPWR sky130_fd_sc_hd__decap_3
XFILLER_29_486 VGND VGND VPWR VPWR sky130_fd_sc_hd__decap_3
XFILLER_84_592 VGND VGND VPWR VPWR sky130_fd_sc_hd__decap_3
XFILLER_56_99 VGND VGND VPWR VPWR sky130_fd_sc_hd__decap_3
XFILLER_16_114 VGND VGND VPWR VPWR sky130_fd_sc_hd__fill_2
XTAP_TAPCELL_ROW_27_621 VGND VPWR sky130_fd_sc_hd__tapvpwrvgnd_1
XFILLER_44_445 VGND VGND VPWR VPWR sky130_fd_sc_hd__decap_3
XFILLER_17_659 VGND VGND VPWR VPWR sky130_fd_sc_hd__decap_3
XFILLER_16_136 VGND VGND VPWR VPWR sky130_fd_sc_hd__decap_3
XFILLER_112_50 VGND VGND VPWR VPWR sky130_fd_sc_hd__decap_3
XFILLER_32_607 VGND VGND VPWR VPWR sky130_fd_sc_hd__decap_3
XFILLER_16_158 VGND VGND VPWR VPWR sky130_fd_sc_hd__decap_3
XTAP_TAPCELL_ROW_123_1863 VGND VPWR sky130_fd_sc_hd__tapvpwrvgnd_1
XTAP_TAPCELL_ROW_55_985 VGND VPWR sky130_fd_sc_hd__tapvpwrvgnd_1
XFILLER_31_106 VGND VGND VPWR VPWR sky130_fd_sc_hd__decap_3
XFILLER_72_43 VGND VGND VPWR VPWR sky130_fd_sc_hd__decap_3
XTAP_TAPCELL_ROW_123_1874 VGND VPWR sky130_fd_sc_hd__tapvpwrvgnd_1
XFILLER_72_54 VGND VGND VPWR VPWR sky130_fd_sc_hd__decap_3
XTAP_TAPCELL_ROW_123_1885 VGND VPWR sky130_fd_sc_hd__tapvpwrvgnd_1
XFILLER_24_180 VGND VGND VPWR VPWR sky130_fd_sc_hd__decap_3
XFILLER_40_640 VGND VGND VPWR VPWR sky130_fd_sc_hd__decap_3
XFILLER_40_651 VGND VGND VPWR VPWR sky130_fd_sc_hd__decap_3
XFILLER_40_684 VGND VGND VPWR VPWR sky130_fd_sc_hd__decap_3
XFILLER_12_386 VGND VGND VPWR VPWR sky130_fd_sc_hd__decap_3
XFILLER_8_379 VGND VGND VPWR VPWR sky130_fd_sc_hd__decap_3
XTAP_TAPCELL_ROW_74_1228 VGND VPWR sky130_fd_sc_hd__tapvpwrvgnd_1
XFILLER_99_629 VGND VGND VPWR VPWR sky130_fd_sc_hd__decap_3
XFILLER_98_106 VGND VGND VPWR VPWR sky130_fd_sc_hd__decap_3
XFILLER_4_563 VGND VGND VPWR VPWR sky130_fd_sc_hd__decap_3
XFILLER_97_40 VGND VGND VPWR VPWR sky130_fd_sc_hd__fill_1
XFILLER_79_364 VGND VGND VPWR VPWR sky130_fd_sc_hd__fill_1
XFILLER_39_206 VGND VGND VPWR VPWR sky130_fd_sc_hd__decap_3
XFILLER_121_461 VGND VGND VPWR VPWR sky130_fd_sc_hd__decap_3
XFILLER_94_312 VGND VGND VPWR VPWR sky130_fd_sc_hd__decap_3
XFILLER_67_537 VGND VGND VPWR VPWR sky130_fd_sc_hd__decap_3
XFILLER_39_228 VGND VGND VPWR VPWR sky130_fd_sc_hd__decap_3
XFILLER_121_494 VGND VGND VPWR VPWR sky130_fd_sc_hd__decap_3
XFILLER_67_559 VGND VGND VPWR VPWR sky130_fd_sc_hd__fill_1
XFILLER_94_345 VGND VGND VPWR VPWR sky130_fd_sc_hd__fill_1
XFILLER_82_507 VGND VGND VPWR VPWR sky130_fd_sc_hd__decap_3
XFILLER_47_250 VGND VGND VPWR VPWR sky130_fd_sc_hd__decap_3
XFILLER_63_721 VGND VGND VPWR VPWR sky130_fd_sc_hd__decap_3
XFILLER_63_732 VGND VGND VPWR VPWR sky130_fd_sc_hd__decap_3
XFILLER_62_220 VGND VGND VPWR VPWR sky130_fd_sc_hd__decap_3
XFILLER_90_540 VGND VGND VPWR VPWR sky130_fd_sc_hd__decap_3
XTAP_TAPCELL_ROW_85_1368 VGND VPWR sky130_fd_sc_hd__tapvpwrvgnd_1
XFILLER_23_607 VGND VGND VPWR VPWR sky130_fd_sc_hd__decap_3
XFILLER_62_253 VGND VGND VPWR VPWR sky130_fd_sc_hd__decap_3
XFILLER_23_629 VGND VGND VPWR VPWR sky130_fd_sc_hd__decap_3
X_6770_ _6960_/CLK _6770_/D VGND VGND VPWR VPWR _6770_/Q sky130_fd_sc_hd__dfxtp_2
XFILLER_90_584 VGND VGND VPWR VPWR sky130_fd_sc_hd__decap_3
XFILLER_90_595 VGND VGND VPWR VPWR sky130_fd_sc_hd__decap_3
XFILLER_16_681 VGND VGND VPWR VPWR sky130_fd_sc_hd__decap_3
XFILLER_50_448 VGND VGND VPWR VPWR sky130_fd_sc_hd__decap_3
X_5721_ _7366_/Q hold932/X _5737_/S VGND VGND VPWR VPWR _6710_/D sky130_fd_sc_hd__mux2_2
XFILLER_31_662 VGND VGND VPWR VPWR sky130_fd_sc_hd__decap_3
XFILLER_31_673 VGND VGND VPWR VPWR sky130_fd_sc_hd__decap_3
X_5652_ _5664_/A VGND VGND VPWR VPWR _5652_/Y sky130_fd_sc_hd__inv_2
X_4603_ hold968/X _4595_/B _3487_/X VGND VGND VPWR VPWR _7279_/D sky130_fd_sc_hd__a21o_2
X_5583_ _5583_/A0 _5094_/X _5595_/B VGND VGND VPWR VPWR _7037_/D sky130_fd_sc_hd__mux2_2
XFILLER_117_712 VGND VGND VPWR VPWR sky130_fd_sc_hd__decap_3
X_4534_ _4534_/A0 _4601_/A0 _4534_/S VGND VGND VPWR VPWR _7312_/D sky130_fd_sc_hd__mux2_2
X_7322_ _7354_/CLK _7322_/D _6602_/Y VGND VGND VPWR VPWR _7322_/Q sky130_fd_sc_hd__dfrtp_2
XFILLER_116_233 VGND VGND VPWR VPWR sky130_fd_sc_hd__decap_3
X_4465_ _5655_/B _5655_/C VGND VGND VPWR VPWR _5650_/A sky130_fd_sc_hd__nor2_2
X_7253_ _7279_/CLK _7253_/D _6533_/Y VGND VGND VPWR VPWR _7253_/Q sky130_fd_sc_hd__dfrtp_2
XFILLER_104_406 VGND VGND VPWR VPWR sky130_fd_sc_hd__fill_1
XFILLER_117_39 VGND VGND VPWR VPWR sky130_fd_sc_hd__decap_3
XFILLER_116_277 VGND VGND VPWR VPWR sky130_fd_sc_hd__decap_3
XFILLER_89_139 VGND VGND VPWR VPWR sky130_fd_sc_hd__fill_2
XFILLER_104_439 VGND VGND VPWR VPWR sky130_fd_sc_hd__decap_3
X_7184_ _7345_/CLK _7184_/D _6464_/Y VGND VGND VPWR VPWR _7184_/Q sky130_fd_sc_hd__dfrtp_2
X_4396_ _4396_/A _4444_/B VGND VGND VPWR VPWR _4648_/A sky130_fd_sc_hd__nor2_2
XFILLER_98_640 VGND VGND VPWR VPWR sky130_fd_sc_hd__decap_3
XFILLER_98_651 VGND VGND VPWR VPWR sky130_fd_sc_hd__decap_3
XTAP_TAPCELL_ROW_5_327 VGND VPWR sky130_fd_sc_hd__tapvpwrvgnd_1
X_3347_ _5640_/B _3509_/B VGND VGND VPWR VPWR _3420_/A sky130_fd_sc_hd__or2_2
XFILLER_97_150 VGND VGND VPWR VPWR sky130_fd_sc_hd__decap_3
XFILLER_100_601 VGND VGND VPWR VPWR sky130_fd_sc_hd__decap_3
XFILLER_98_684 VGND VGND VPWR VPWR sky130_fd_sc_hd__decap_3
XFILLER_58_515 VGND VGND VPWR VPWR sky130_fd_sc_hd__decap_3
XFILLER_112_461 VGND VGND VPWR VPWR sky130_fd_sc_hd__fill_1
XTAP_TAPCELL_ROW_5_338 VGND VPWR sky130_fd_sc_hd__tapvpwrvgnd_1
XFILLER_97_172 VGND VGND VPWR VPWR sky130_fd_sc_hd__fill_2
Xhold1002 _7262_/Q VGND VGND VPWR VPWR _4998_/A0 sky130_fd_sc_hd__dlygate4sd3_1
XFILLER_85_323 VGND VGND VPWR VPWR sky130_fd_sc_hd__decap_3
XFILLER_112_483 VGND VGND VPWR VPWR sky130_fd_sc_hd__decap_3
Xhold1013 _7197_/Q VGND VGND VPWR VPWR _5266_/A0 sky130_fd_sc_hd__dlygate4sd3_1
XFILLER_97_183 VGND VGND VPWR VPWR sky130_fd_sc_hd__decap_3
XFILLER_100_634 VGND VGND VPWR VPWR sky130_fd_sc_hd__decap_3
Xhold1024 _7259_/Q VGND VGND VPWR VPWR _5041_/A0 sky130_fd_sc_hd__dlygate4sd3_1
XFILLER_100_645 VGND VGND VPWR VPWR sky130_fd_sc_hd__decap_3
Xhold1035 _7208_/Q VGND VGND VPWR VPWR _5243_/A0 sky130_fd_sc_hd__dlygate4sd3_1
XFILLER_85_345 VGND VGND VPWR VPWR sky130_fd_sc_hd__decap_3
Xhold1046 _7253_/Q VGND VGND VPWR VPWR _5126_/A0 sky130_fd_sc_hd__dlygate4sd3_1
X_5017_ _5018_/A _5017_/B VGND VGND VPWR VPWR _5017_/Y sky130_fd_sc_hd__xnor2_2
Xhold1057 _6694_/Q VGND VGND VPWR VPWR _5688_/A1 sky130_fd_sc_hd__dlygate4sd3_1
XFILLER_100_678 VGND VGND VPWR VPWR sky130_fd_sc_hd__decap_3
Xhold1068 _7250_/Q VGND VGND VPWR VPWR _5140_/A0 sky130_fd_sc_hd__dlygate4sd3_1
Xhold1079 _7128_/Q VGND VGND VPWR VPWR _5411_/A0 sky130_fd_sc_hd__dlygate4sd3_1
XFILLER_85_389 VGND VGND VPWR VPWR sky130_fd_sc_hd__decap_3
XFILLER_54_710 VGND VGND VPWR VPWR sky130_fd_sc_hd__decap_3
XFILLER_66_581 VGND VGND VPWR VPWR sky130_fd_sc_hd__decap_3
XFILLER_38_283 VGND VGND VPWR VPWR sky130_fd_sc_hd__decap_3
XFILLER_53_220 VGND VGND VPWR VPWR sky130_fd_sc_hd__decap_3
XFILLER_26_434 VGND VGND VPWR VPWR sky130_fd_sc_hd__decap_3
XFILLER_53_231 VGND VGND VPWR VPWR sky130_fd_sc_hd__decap_3
XFILLER_14_607 VGND VGND VPWR VPWR sky130_fd_sc_hd__decap_3
XFILLER_81_573 VGND VGND VPWR VPWR sky130_fd_sc_hd__decap_3
XFILLER_41_404 VGND VGND VPWR VPWR sky130_fd_sc_hd__decap_3
X_6968_ clkload8/A _6968_/D VGND VGND VPWR VPWR _6968_/Q sky130_fd_sc_hd__dfxtp_2
XTAP_TAPCELL_ROW_52_944 VGND VPWR sky130_fd_sc_hd__tapvpwrvgnd_1
XFILLER_13_139 VGND VGND VPWR VPWR sky130_fd_sc_hd__decap_3
XFILLER_22_640 VGND VGND VPWR VPWR sky130_fd_sc_hd__decap_3
X_6899_ clkload5/A _6899_/D VGND VGND VPWR VPWR _6899_/Q sky130_fd_sc_hd__dfxtp_2
XFILLER_22_651 VGND VGND VPWR VPWR sky130_fd_sc_hd__decap_3
XFILLER_42_46 VGND VGND VPWR VPWR sky130_fd_sc_hd__decap_3
XFILLER_22_684 VGND VGND VPWR VPWR sky130_fd_sc_hd__decap_3
XFILLER_21_172 VGND VGND VPWR VPWR sky130_fd_sc_hd__decap_3
XFILLER_108_701 VGND VGND VPWR VPWR sky130_fd_sc_hd__decap_3
XFILLER_5_305 VGND VGND VPWR VPWR sky130_fd_sc_hd__decap_3
XFILLER_5_327 VGND VGND VPWR VPWR sky130_fd_sc_hd__decap_3
XFILLER_108_734 VGND VGND VPWR VPWR sky130_fd_sc_hd__fill_1
XFILLER_107_211 VGND VGND VPWR VPWR sky130_fd_sc_hd__decap_3
XFILLER_123_704 VGND VGND VPWR VPWR sky130_fd_sc_hd__decap_3
XFILLER_107_255 VGND VGND VPWR VPWR sky130_fd_sc_hd__decap_3
XFILLER_101_3 VGND VGND VPWR VPWR sky130_fd_sc_hd__decap_3
XFILLER_1_511 VGND VGND VPWR VPWR sky130_fd_sc_hd__decap_3
Xhold880 _7083_/Q VGND VGND VPWR VPWR _7083_/D sky130_fd_sc_hd__dlygate4sd3_1
Xhold891 _7101_/Q VGND VGND VPWR VPWR _7101_/D sky130_fd_sc_hd__dlygate4sd3_1
XFILLER_3_29 VGND VGND VPWR VPWR sky130_fd_sc_hd__decap_3
XFILLER_1_544 VGND VGND VPWR VPWR sky130_fd_sc_hd__decap_3
XFILLER_89_662 VGND VGND VPWR VPWR sky130_fd_sc_hd__decap_3
XFILLER_89_673 VGND VGND VPWR VPWR sky130_fd_sc_hd__decap_3
XFILLER_67_21 VGND VGND VPWR VPWR sky130_fd_sc_hd__decap_3
XFILLER_103_461 VGND VGND VPWR VPWR sky130_fd_sc_hd__fill_2
XFILLER_1_588 VGND VGND VPWR VPWR sky130_fd_sc_hd__decap_3
XFILLER_103_472 VGND VGND VPWR VPWR sky130_fd_sc_hd__decap_3
XFILLER_76_312 VGND VGND VPWR VPWR sky130_fd_sc_hd__fill_2
XFILLER_67_54 VGND VGND VPWR VPWR sky130_fd_sc_hd__fill_2
XFILLER_49_537 VGND VGND VPWR VPWR sky130_fd_sc_hd__decap_3
XFILLER_76_323 VGND VGND VPWR VPWR sky130_fd_sc_hd__decap_3
XFILLER_76_345 VGND VGND VPWR VPWR sky130_fd_sc_hd__fill_2
XFILLER_91_304 VGND VGND VPWR VPWR sky130_fd_sc_hd__decap_3
XFILLER_36_209 VGND VGND VPWR VPWR sky130_fd_sc_hd__decap_3
XFILLER_29_250 VGND VGND VPWR VPWR sky130_fd_sc_hd__fill_1
XFILLER_123_60 VGND VGND VPWR VPWR sky130_fd_sc_hd__decap_3
XFILLER_45_721 VGND VGND VPWR VPWR sky130_fd_sc_hd__decap_3
XFILLER_91_337 VGND VGND VPWR VPWR sky130_fd_sc_hd__decap_3
XFILLER_45_732 VGND VGND VPWR VPWR sky130_fd_sc_hd__decap_3
XFILLER_83_42 VGND VGND VPWR VPWR sky130_fd_sc_hd__decap_3
XFILLER_44_231 VGND VGND VPWR VPWR sky130_fd_sc_hd__decap_3
XFILLER_72_551 VGND VGND VPWR VPWR sky130_fd_sc_hd__decap_3
XFILLER_44_253 VGND VGND VPWR VPWR sky130_fd_sc_hd__fill_1
XFILLER_17_467 VGND VGND VPWR VPWR sky130_fd_sc_hd__decap_3
XFILLER_60_713 VGND VGND VPWR VPWR sky130_fd_sc_hd__decap_3
XFILLER_83_86 VGND VGND VPWR VPWR sky130_fd_sc_hd__decap_3
XFILLER_83_97 VGND VGND VPWR VPWR sky130_fd_sc_hd__decap_3
XFILLER_72_595 VGND VGND VPWR VPWR sky130_fd_sc_hd__decap_3
XFILLER_9_600 VGND VGND VPWR VPWR sky130_fd_sc_hd__decap_3
XFILLER_13_662 VGND VGND VPWR VPWR sky130_fd_sc_hd__decap_3
XFILLER_13_673 VGND VGND VPWR VPWR sky130_fd_sc_hd__decap_3
XFILLER_9_644 VGND VGND VPWR VPWR sky130_fd_sc_hd__decap_3
XFILLER_40_492 VGND VGND VPWR VPWR sky130_fd_sc_hd__decap_3
XFILLER_12_183 VGND VGND VPWR VPWR sky130_fd_sc_hd__fill_1
XFILLER_9_688 VGND VGND VPWR VPWR sky130_fd_sc_hd__decap_3
XFILLER_66_6 VGND VGND VPWR VPWR sky130_fd_sc_hd__decap_3
XTAP_TAPCELL_ROW_10_395 VGND VPWR sky130_fd_sc_hd__tapvpwrvgnd_1
XFILLER_114_704 VGND VGND VPWR VPWR sky130_fd_sc_hd__decap_3
X_4250_ _7101_/Q _4351_/A2 _4352_/B1 _7165_/Q VGND VGND VPWR VPWR _4250_/X sky130_fd_sc_hd__a22o_2
XFILLER_113_225 VGND VGND VPWR VPWR sky130_fd_sc_hd__decap_3
X_4181_ _7200_/Q _3966_/S _4268_/B1 _7392_/Q VGND VGND VPWR VPWR _4181_/X sky130_fd_sc_hd__a22o_2
XFILLER_67_301 VGND VGND VPWR VPWR sky130_fd_sc_hd__decap_3
XFILLER_79_172 VGND VGND VPWR VPWR sky130_fd_sc_hd__decap_3
XFILLER_95_632 VGND VGND VPWR VPWR sky130_fd_sc_hd__decap_3
XFILLER_94_131 VGND VGND VPWR VPWR sky130_fd_sc_hd__decap_3
XFILLER_95_665 VGND VGND VPWR VPWR sky130_fd_sc_hd__decap_3
XFILLER_95_676 VGND VGND VPWR VPWR sky130_fd_sc_hd__decap_3
XFILLER_55_518 VGND VGND VPWR VPWR sky130_fd_sc_hd__fill_1
XFILLER_27_209 VGND VGND VPWR VPWR sky130_fd_sc_hd__decap_3
XFILLER_82_315 VGND VGND VPWR VPWR sky130_fd_sc_hd__decap_3
XFILLER_48_570 VGND VGND VPWR VPWR sky130_fd_sc_hd__fill_1
XFILLER_36_710 VGND VGND VPWR VPWR sky130_fd_sc_hd__decap_3
XFILLER_94_197 VGND VGND VPWR VPWR sky130_fd_sc_hd__decap_3
XFILLER_35_231 VGND VGND VPWR VPWR sky130_fd_sc_hd__decap_3
X_6822_ _6967_/CLK _6822_/D VGND VGND VPWR VPWR _6822_/Q sky130_fd_sc_hd__dfxtp_2
XFILLER_63_573 VGND VGND VPWR VPWR sky130_fd_sc_hd__decap_3
XFILLER_35_264 VGND VGND VPWR VPWR sky130_fd_sc_hd__fill_2
XFILLER_51_724 VGND VGND VPWR VPWR sky130_fd_sc_hd__decap_3
XFILLER_23_415 VGND VGND VPWR VPWR sky130_fd_sc_hd__decap_3
XFILLER_50_212 VGND VGND VPWR VPWR sky130_fd_sc_hd__decap_3
XTAP_TAPCELL_ROW_18_495 VGND VPWR sky130_fd_sc_hd__tapvpwrvgnd_1
X_6753_ _6978_/CLK _6753_/D VGND VGND VPWR VPWR _6753_/Q sky130_fd_sc_hd__dfxtp_2
XFILLER_50_289 VGND VGND VPWR VPWR sky130_fd_sc_hd__decap_3
XFILLER_31_470 VGND VGND VPWR VPWR sky130_fd_sc_hd__decap_3
X_3896_ _3880_/X _3885_/X _3895_/X _3991_/A VGND VGND VPWR VPWR _3896_/Y sky130_fd_sc_hd__o31ai_2
X_6684_ _6684_/A VGND VGND VPWR VPWR _6684_/Y sky130_fd_sc_hd__inv_2
XTAP_TAPCELL_ROW_98_1537 VGND VPWR sky130_fd_sc_hd__tapvpwrvgnd_1
XFILLER_117_520 VGND VGND VPWR VPWR sky130_fd_sc_hd__decap_3
X_5566_ hold975/X _4983_/A _4860_/Y VGND VGND VPWR VPWR _7051_/D sky130_fd_sc_hd__o21a_2
XFILLER_117_553 VGND VGND VPWR VPWR sky130_fd_sc_hd__decap_3
X_7305_ _7399_/CLK _7305_/D _6585_/Y VGND VGND VPWR VPWR _7305_/Q sky130_fd_sc_hd__dfrtp_2
XFILLER_117_564 VGND VGND VPWR VPWR sky130_fd_sc_hd__decap_3
X_4517_ _4517_/A0 _7289_/Q _4520_/S VGND VGND VPWR VPWR _7321_/D sky130_fd_sc_hd__mux2_2
XFILLER_105_715 VGND VGND VPWR VPWR sky130_fd_sc_hd__decap_3
XFILLER_117_597 VGND VGND VPWR VPWR sky130_fd_sc_hd__decap_3
XFILLER_104_214 VGND VGND VPWR VPWR sky130_fd_sc_hd__decap_3
X_7236_ _7362_/CLK _7236_/D _6516_/Y VGND VGND VPWR VPWR _7236_/Q sky130_fd_sc_hd__dfrtp_2
X_4448_ _4444_/X _4447_/Y _4413_/A VGND VGND VPWR VPWR _4448_/X sky130_fd_sc_hd__o21a_2
XFILLER_120_707 VGND VGND VPWR VPWR sky130_fd_sc_hd__decap_3
X_4379_ _4938_/B _4379_/B VGND VGND VPWR VPWR _4937_/A sky130_fd_sc_hd__or2_2
X_7167_ _7360_/CLK _7167_/D _6447_/Y VGND VGND VPWR VPWR _7167_/Q sky130_fd_sc_hd__dfrtp_2
XFILLER_86_610 VGND VGND VPWR VPWR sky130_fd_sc_hd__decap_3
XFILLER_58_312 VGND VGND VPWR VPWR sky130_fd_sc_hd__decap_3
XFILLER_98_492 VGND VGND VPWR VPWR sky130_fd_sc_hd__fill_2
XFILLER_86_643 VGND VGND VPWR VPWR sky130_fd_sc_hd__fill_1
XFILLER_58_334 VGND VGND VPWR VPWR sky130_fd_sc_hd__decap_3
XFILLER_112_280 VGND VGND VPWR VPWR sky130_fd_sc_hd__decap_3
X_7098_ _7354_/CLK _7098_/D _6378_/Y VGND VGND VPWR VPWR _7098_/Q sky130_fd_sc_hd__dfrtp_2
XFILLER_86_654 VGND VGND VPWR VPWR sky130_fd_sc_hd__decap_3
XFILLER_46_507 VGND VGND VPWR VPWR sky130_fd_sc_hd__fill_1
XFILLER_86_687 VGND VGND VPWR VPWR sky130_fd_sc_hd__decap_3
XFILLER_85_164 VGND VGND VPWR VPWR sky130_fd_sc_hd__decap_3
XFILLER_46_529 VGND VGND VPWR VPWR sky130_fd_sc_hd__decap_3
XFILLER_85_175 VGND VGND VPWR VPWR sky130_fd_sc_hd__decap_3
XFILLER_73_315 VGND VGND VPWR VPWR sky130_fd_sc_hd__decap_3
XFILLER_37_57 VGND VGND VPWR VPWR sky130_fd_sc_hd__fill_1
XFILLER_27_721 VGND VGND VPWR VPWR sky130_fd_sc_hd__decap_3
XFILLER_100_486 VGND VGND VPWR VPWR sky130_fd_sc_hd__decap_3
XFILLER_73_337 VGND VGND VPWR VPWR sky130_fd_sc_hd__decap_3
XFILLER_27_732 VGND VGND VPWR VPWR sky130_fd_sc_hd__decap_3
XFILLER_26_220 VGND VGND VPWR VPWR sky130_fd_sc_hd__fill_2
XFILLER_73_359 VGND VGND VPWR VPWR sky130_fd_sc_hd__fill_1
XTAP_TAPCELL_ROW_107_1655 VGND VPWR sky130_fd_sc_hd__tapvpwrvgnd_1
XFILLER_54_551 VGND VGND VPWR VPWR sky130_fd_sc_hd__decap_3
XFILLER_26_253 VGND VGND VPWR VPWR sky130_fd_sc_hd__decap_3
XFILLER_42_713 VGND VGND VPWR VPWR sky130_fd_sc_hd__decap_3
XFILLER_14_404 VGND VGND VPWR VPWR sky130_fd_sc_hd__decap_3
XTAP_TAPCELL_ROW_120_1822 VGND VPWR sky130_fd_sc_hd__tapvpwrvgnd_1
XFILLER_41_234 VGND VGND VPWR VPWR sky130_fd_sc_hd__decap_3
XTAP_TAPCELL_ROW_120_1833 VGND VPWR sky130_fd_sc_hd__tapvpwrvgnd_1
XFILLER_41_278 VGND VGND VPWR VPWR sky130_fd_sc_hd__fill_2
XFILLER_10_610 VGND VGND VPWR VPWR sky130_fd_sc_hd__decap_3
XFILLER_22_492 VGND VGND VPWR VPWR sky130_fd_sc_hd__decap_3
XFILLER_10_643 VGND VGND VPWR VPWR sky130_fd_sc_hd__fill_1
XFILLER_10_654 VGND VGND VPWR VPWR sky130_fd_sc_hd__decap_3
XFILLER_6_625 VGND VGND VPWR VPWR sky130_fd_sc_hd__decap_3
XFILLER_5_113 VGND VGND VPWR VPWR sky130_fd_sc_hd__decap_3
XFILLER_10_687 VGND VGND VPWR VPWR sky130_fd_sc_hd__decap_3
XFILLER_108_542 VGND VGND VPWR VPWR sky130_fd_sc_hd__decap_3
XFILLER_6_669 VGND VGND VPWR VPWR sky130_fd_sc_hd__decap_3
XFILLER_108_575 VGND VGND VPWR VPWR sky130_fd_sc_hd__decap_3
XTAP_TAPCELL_ROW_118_1795 VGND VPWR sky130_fd_sc_hd__tapvpwrvgnd_1
XFILLER_118_71 VGND VGND VPWR VPWR sky130_fd_sc_hd__decap_3
XFILLER_123_545 VGND VGND VPWR VPWR sky130_fd_sc_hd__decap_3
XFILLER_123_567 VGND VGND VPWR VPWR sky130_fd_sc_hd__decap_3
XFILLER_96_418 VGND VGND VPWR VPWR sky130_fd_sc_hd__fill_2
XFILLER_111_718 VGND VGND VPWR VPWR sky130_fd_sc_hd__decap_3
XFILLER_78_75 VGND VGND VPWR VPWR sky130_fd_sc_hd__decap_3
XFILLER_123_589 VGND VGND VPWR VPWR sky130_fd_sc_hd__decap_3
XFILLER_111_729 VGND VGND VPWR VPWR sky130_fd_sc_hd__decap_3
XFILLER_110_206 VGND VGND VPWR VPWR sky130_fd_sc_hd__decap_3
XFILLER_89_470 VGND VGND VPWR VPWR sky130_fd_sc_hd__decap_3
XFILLER_78_97 VGND VGND VPWR VPWR sky130_fd_sc_hd__decap_3
XFILLER_77_632 VGND VGND VPWR VPWR sky130_fd_sc_hd__decap_3
XFILLER_110_239 VGND VGND VPWR VPWR sky130_fd_sc_hd__decap_3
XFILLER_77_665 VGND VGND VPWR VPWR sky130_fd_sc_hd__decap_3
XFILLER_49_356 VGND VGND VPWR VPWR sky130_fd_sc_hd__decap_3
XFILLER_77_676 VGND VGND VPWR VPWR sky130_fd_sc_hd__decap_3
XFILLER_92_613 VGND VGND VPWR VPWR sky130_fd_sc_hd__decap_3
XFILLER_49_378 VGND VGND VPWR VPWR sky130_fd_sc_hd__decap_3
XFILLER_49_389 VGND VGND VPWR VPWR sky130_fd_sc_hd__decap_3
XFILLER_18_710 VGND VGND VPWR VPWR sky130_fd_sc_hd__decap_3
XFILLER_76_197 VGND VGND VPWR VPWR sky130_fd_sc_hd__decap_3
XFILLER_94_85 VGND VGND VPWR VPWR sky130_fd_sc_hd__fill_1
XFILLER_92_657 VGND VGND VPWR VPWR sky130_fd_sc_hd__decap_3
XFILLER_91_134 VGND VGND VPWR VPWR sky130_fd_sc_hd__decap_3
XFILLER_64_348 VGND VGND VPWR VPWR sky130_fd_sc_hd__decap_3
XFILLER_17_231 VGND VGND VPWR VPWR sky130_fd_sc_hd__decap_3
XTAP_TAPCELL_ROW_35_719 VGND VPWR sky130_fd_sc_hd__tapvpwrvgnd_1
XFILLER_91_167 VGND VGND VPWR VPWR sky130_fd_sc_hd__fill_1
XFILLER_91_178 VGND VGND VPWR VPWR sky130_fd_sc_hd__decap_3
XFILLER_27_90 VGND VGND VPWR VPWR sky130_fd_sc_hd__decap_3
XFILLER_33_724 VGND VGND VPWR VPWR sky130_fd_sc_hd__decap_3
XTAP_TAPCELL_ROW_82_1327 VGND VPWR sky130_fd_sc_hd__tapvpwrvgnd_1
XFILLER_45_595 VGND VGND VPWR VPWR sky130_fd_sc_hd__decap_3
XTAP_TAPCELL_ROW_82_1338 VGND VPWR sky130_fd_sc_hd__tapvpwrvgnd_1
XFILLER_32_234 VGND VGND VPWR VPWR sky130_fd_sc_hd__decap_3
XFILLER_60_565 VGND VGND VPWR VPWR sky130_fd_sc_hd__decap_3
XTAP_TAPCELL_ROW_15_465 VGND VPWR sky130_fd_sc_hd__tapvpwrvgnd_1
X_3750_ _3750_/A1 _3857_/A2 place268/X VGND VGND VPWR VPWR _7398_/D sky130_fd_sc_hd__a21bo_2
XFILLER_13_492 VGND VGND VPWR VPWR sky130_fd_sc_hd__fill_2
XFILLER_9_452 VGND VGND VPWR VPWR sky130_fd_sc_hd__decap_3
X_3681_ _3674_/Y _3898_/B1 _3917_/A2 _3676_/Y _3680_/X VGND VGND VPWR VPWR _3682_/B
+ sky130_fd_sc_hd__a221o_2
XFILLER_114_523 VGND VGND VPWR VPWR sky130_fd_sc_hd__decap_3
X_4302_ _7224_/Q _4349_/B1 _4248_/A _4301_/X VGND VGND VPWR VPWR _4302_/X sky130_fd_sc_hd__a211o_2
XFILLER_99_234 VGND VGND VPWR VPWR sky130_fd_sc_hd__decap_3
XFILLER_5_691 VGND VGND VPWR VPWR sky130_fd_sc_hd__decap_3
X_5282_ hold937/X _5238_/X _3610_/Y VGND VGND VPWR VPWR _7189_/D sky130_fd_sc_hd__a21o_2
XFILLER_114_545 VGND VGND VPWR VPWR sky130_fd_sc_hd__decap_3
XTAP_TAPCELL_ROW_93_1478 VGND VPWR sky130_fd_sc_hd__tapvpwrvgnd_1
XFILLER_99_256 VGND VGND VPWR VPWR sky130_fd_sc_hd__decap_3
XFILLER_102_707 VGND VGND VPWR VPWR sky130_fd_sc_hd__decap_3
XFILLER_114_578 VGND VGND VPWR VPWR sky130_fd_sc_hd__decap_3
X_4233_ _7323_/Q _3989_/S _4520_/S _7291_/Q VGND VGND VPWR VPWR _4233_/X sky130_fd_sc_hd__a22o_2
X_7021_ _7359_/CLK _7021_/D _6301_/Y VGND VGND VPWR VPWR _7021_/Q sky130_fd_sc_hd__dfrtp_2
XFILLER_114_589 VGND VGND VPWR VPWR sky130_fd_sc_hd__decap_3
XFILLER_68_610 VGND VGND VPWR VPWR sky130_fd_sc_hd__decap_3
XFILLER_101_228 VGND VGND VPWR VPWR sky130_fd_sc_hd__decap_3
XFILLER_68_643 VGND VGND VPWR VPWR sky130_fd_sc_hd__fill_1
X_4164_ _7105_/Q _4351_/A2 _4267_/B1 _7169_/Q VGND VGND VPWR VPWR _4164_/X sky130_fd_sc_hd__a22o_2
XFILLER_68_654 VGND VGND VPWR VPWR sky130_fd_sc_hd__decap_3
XFILLER_114_18 VGND VGND VPWR VPWR sky130_fd_sc_hd__decap_3
XFILLER_114_29 VGND VGND VPWR VPWR sky130_fd_sc_hd__decap_3
XFILLER_28_507 VGND VGND VPWR VPWR sky130_fd_sc_hd__fill_1
XFILLER_95_473 VGND VGND VPWR VPWR sky130_fd_sc_hd__fill_2
XFILLER_68_687 VGND VGND VPWR VPWR sky130_fd_sc_hd__decap_3
X_4095_ _4095_/A _4210_/B VGND VGND VPWR VPWR _4096_/B sky130_fd_sc_hd__nand2_2
XFILLER_95_484 VGND VGND VPWR VPWR sky130_fd_sc_hd__decap_3
XFILLER_67_175 VGND VGND VPWR VPWR sky130_fd_sc_hd__decap_3
XFILLER_83_635 VGND VGND VPWR VPWR sky130_fd_sc_hd__decap_3
XFILLER_67_186 VGND VGND VPWR VPWR sky130_fd_sc_hd__decap_3
XFILLER_55_337 VGND VGND VPWR VPWR sky130_fd_sc_hd__decap_3
XFILLER_83_668 VGND VGND VPWR VPWR sky130_fd_sc_hd__decap_3
XFILLER_82_134 VGND VGND VPWR VPWR sky130_fd_sc_hd__decap_3
XFILLER_83_679 VGND VGND VPWR VPWR sky130_fd_sc_hd__decap_3
XFILLER_70_318 VGND VGND VPWR VPWR sky130_fd_sc_hd__decap_3
XFILLER_24_713 VGND VGND VPWR VPWR sky130_fd_sc_hd__decap_3
XFILLER_36_584 VGND VGND VPWR VPWR sky130_fd_sc_hd__decap_3
XFILLER_23_201 VGND VGND VPWR VPWR sky130_fd_sc_hd__decap_3
XFILLER_51_521 VGND VGND VPWR VPWR sky130_fd_sc_hd__decap_3
XFILLER_36_595 VGND VGND VPWR VPWR sky130_fd_sc_hd__decap_3
X_6805_ _7403_/CLK _6805_/D VGND VGND VPWR VPWR _6805_/Q sky130_fd_sc_hd__dfxtp_2
Xplace370 _4248_/A VGND VGND VPWR VPWR _4347_/C1 sky130_fd_sc_hd__buf_2
Xplace381 _3442_/A VGND VGND VPWR VPWR _5104_/A sky130_fd_sc_hd__buf_2
XFILLER_23_256 VGND VGND VPWR VPWR sky130_fd_sc_hd__decap_3
X_4997_ _4997_/A1 _6992_/D _4983_/X _4996_/X VGND VGND VPWR VPWR _4997_/X sky130_fd_sc_hd__a211o_2
Xplace392 _5666_/A VGND VGND VPWR VPWR _5642_/A sky130_fd_sc_hd__buf_2
XFILLER_11_429 VGND VGND VPWR VPWR sky130_fd_sc_hd__decap_3
X_6736_ _6978_/CLK _6736_/D VGND VGND VPWR VPWR _6736_/Q sky130_fd_sc_hd__dfxtp_2
XFILLER_51_598 VGND VGND VPWR VPWR sky130_fd_sc_hd__decap_3
XTAP_TAPCELL_ROW_102_1596 VGND VPWR sky130_fd_sc_hd__tapvpwrvgnd_1
X_6667_ _6667_/A VGND VGND VPWR VPWR _6667_/Y sky130_fd_sc_hd__inv_2
X_3879_ _6747_/Q _3888_/A2 _3891_/A2 _6735_/Q _3878_/X VGND VGND VPWR VPWR _3879_/X
+ sky130_fd_sc_hd__a221o_2
X_6598_ _6598_/A VGND VGND VPWR VPWR _6598_/Y sky130_fd_sc_hd__inv_2
XFILLER_3_606 VGND VGND VPWR VPWR sky130_fd_sc_hd__decap_3
XFILLER_3_617 VGND VGND VPWR VPWR sky130_fd_sc_hd__decap_3
XFILLER_105_567 VGND VGND VPWR VPWR sky130_fd_sc_hd__decap_3
XFILLER_120_504 VGND VGND VPWR VPWR sky130_fd_sc_hd__decap_3
X_7219_ _7318_/CLK _7219_/D _6499_/Y VGND VGND VPWR VPWR _7219_/Q sky130_fd_sc_hd__dfrtp_2
XFILLER_48_23 VGND VGND VPWR VPWR sky130_fd_sc_hd__decap_3
XFILLER_59_632 VGND VGND VPWR VPWR sky130_fd_sc_hd__decap_3
XFILLER_120_548 VGND VGND VPWR VPWR sky130_fd_sc_hd__decap_3
XFILLER_86_451 VGND VGND VPWR VPWR sky130_fd_sc_hd__decap_3
XFILLER_59_665 VGND VGND VPWR VPWR sky130_fd_sc_hd__decap_3
XFILLER_59_676 VGND VGND VPWR VPWR sky130_fd_sc_hd__decap_3
XFILLER_74_613 VGND VGND VPWR VPWR sky130_fd_sc_hd__decap_3
XFILLER_58_164 VGND VGND VPWR VPWR sky130_fd_sc_hd__decap_3
XFILLER_46_304 VGND VGND VPWR VPWR sky130_fd_sc_hd__decap_3
XFILLER_46_315 VGND VGND VPWR VPWR sky130_fd_sc_hd__decap_3
XFILLER_100_283 VGND VGND VPWR VPWR sky130_fd_sc_hd__decap_3
XFILLER_74_657 VGND VGND VPWR VPWR sky130_fd_sc_hd__decap_3
XFILLER_104_62 VGND VGND VPWR VPWR sky130_fd_sc_hd__fill_1
XFILLER_27_551 VGND VGND VPWR VPWR sky130_fd_sc_hd__decap_3
XFILLER_27_584 VGND VGND VPWR VPWR sky130_fd_sc_hd__decap_3
XFILLER_15_724 VGND VGND VPWR VPWR sky130_fd_sc_hd__decap_3
XFILLER_82_690 VGND VGND VPWR VPWR sky130_fd_sc_hd__decap_3
XFILLER_64_88 VGND VGND VPWR VPWR sky130_fd_sc_hd__decap_3
XFILLER_54_381 VGND VGND VPWR VPWR sky130_fd_sc_hd__decap_3
XFILLER_120_50 VGND VGND VPWR VPWR sky130_fd_sc_hd__decap_3
XFILLER_30_716 VGND VGND VPWR VPWR sky130_fd_sc_hd__decap_3
XFILLER_9_39 VGND VGND VPWR VPWR sky130_fd_sc_hd__fill_1
XFILLER_42_587 VGND VGND VPWR VPWR sky130_fd_sc_hd__fill_1
XFILLER_42_598 VGND VGND VPWR VPWR sky130_fd_sc_hd__decap_3
XFILLER_120_83 VGND VGND VPWR VPWR sky130_fd_sc_hd__fill_1
Xfanout60 _6581_/A VGND VGND VPWR VPWR _6613_/A sky130_fd_sc_hd__buf_1
XFILLER_120_94 VGND VGND VPWR VPWR sky130_fd_sc_hd__decap_3
XTAP_TAPCELL_ROW_12_424 VGND VPWR sky130_fd_sc_hd__tapvpwrvgnd_1
Xfanout71 _6288_/A VGND VGND VPWR VPWR _6278_/A sky130_fd_sc_hd__buf_1
XFILLER_80_76 VGND VGND VPWR VPWR sky130_fd_sc_hd__decap_3
XTAP_TAPCELL_ROW_40_788 VGND VPWR sky130_fd_sc_hd__tapvpwrvgnd_1
XFILLER_6_444 VGND VGND VPWR VPWR sky130_fd_sc_hd__decap_3
XFILLER_6_466 VGND VGND VPWR VPWR sky130_fd_sc_hd__fill_1
XFILLER_108_350 VGND VGND VPWR VPWR sky130_fd_sc_hd__decap_3
XFILLER_6_477 VGND VGND VPWR VPWR sky130_fd_sc_hd__fill_1
XFILLER_89_52 VGND VGND VPWR VPWR sky130_fd_sc_hd__decap_3
XFILLER_108_361 VGND VGND VPWR VPWR sky130_fd_sc_hd__decap_3
XFILLER_123_320 VGND VGND VPWR VPWR sky130_fd_sc_hd__decap_3
XFILLER_97_727 VGND VGND VPWR VPWR sky130_fd_sc_hd__fill_1
XFILLER_2_672 VGND VGND VPWR VPWR sky130_fd_sc_hd__decap_3
XFILLER_111_537 VGND VGND VPWR VPWR sky130_fd_sc_hd__decap_3
XFILLER_1_182 VGND VGND VPWR VPWR sky130_fd_sc_hd__decap_3
XFILLER_77_473 VGND VGND VPWR VPWR sky130_fd_sc_hd__decap_3
XFILLER_65_613 VGND VGND VPWR VPWR sky130_fd_sc_hd__decap_3
XFILLER_92_410 VGND VGND VPWR VPWR sky130_fd_sc_hd__decap_3
XFILLER_49_175 VGND VGND VPWR VPWR sky130_fd_sc_hd__decap_3
XFILLER_65_635 VGND VGND VPWR VPWR sky130_fd_sc_hd__decap_3
XFILLER_92_432 VGND VGND VPWR VPWR sky130_fd_sc_hd__decap_3
XFILLER_37_337 VGND VGND VPWR VPWR sky130_fd_sc_hd__decap_3
XFILLER_65_668 VGND VGND VPWR VPWR sky130_fd_sc_hd__decap_3
XFILLER_65_679 VGND VGND VPWR VPWR sky130_fd_sc_hd__decap_3
XFILLER_92_465 VGND VGND VPWR VPWR sky130_fd_sc_hd__decap_3
XTAP_TAPCELL_ROW_48_888 VGND VPWR sky130_fd_sc_hd__tapvpwrvgnd_1
XFILLER_80_616 VGND VGND VPWR VPWR sky130_fd_sc_hd__decap_3
XFILLER_52_307 VGND VGND VPWR VPWR sky130_fd_sc_hd__fill_1
X_4920_ _4920_/A _4920_/B VGND VGND VPWR VPWR _4920_/Y sky130_fd_sc_hd__xnor2_2
XFILLER_52_329 VGND VGND VPWR VPWR sky130_fd_sc_hd__decap_3
XFILLER_18_584 VGND VGND VPWR VPWR sky130_fd_sc_hd__decap_3
XFILLER_18_595 VGND VGND VPWR VPWR sky130_fd_sc_hd__decap_3
X_4851_ _4633_/A _4142_/X _4849_/Y _4850_/Y _4969_/B VGND VGND VPWR VPWR _4855_/B
+ sky130_fd_sc_hd__o311a_2
XFILLER_60_362 VGND VGND VPWR VPWR sky130_fd_sc_hd__fill_2
XFILLER_33_587 VGND VGND VPWR VPWR sky130_fd_sc_hd__decap_3
XFILLER_21_727 VGND VGND VPWR VPWR sky130_fd_sc_hd__fill_1
X_3802_ _3733_/X _3794_/X _3796_/X _3746_/X _3801_/X VGND VGND VPWR VPWR _3802_/X
+ sky130_fd_sc_hd__a221o_2
X_4782_ _4413_/A _4444_/X _4780_/Y _4969_/B VGND VGND VPWR VPWR _4782_/Y sky130_fd_sc_hd__o31ai_2
X_6521_ _6649_/A VGND VGND VPWR VPWR _6521_/Y sky130_fd_sc_hd__inv_2
XFILLER_20_259 VGND VGND VPWR VPWR sky130_fd_sc_hd__decap_3
XFILLER_119_615 VGND VGND VPWR VPWR sky130_fd_sc_hd__fill_1
X_3733_ _3746_/A _3741_/B _3733_/C VGND VGND VPWR VPWR _3733_/X sky130_fd_sc_hd__and3_2
XFILLER_119_626 VGND VGND VPWR VPWR sky130_fd_sc_hd__decap_3
XFILLER_118_103 VGND VGND VPWR VPWR sky130_fd_sc_hd__decap_3
XFILLER_9_260 VGND VGND VPWR VPWR sky130_fd_sc_hd__decap_3
XTAP_TAPCELL_ROW_95_1507 VGND VPWR sky130_fd_sc_hd__tapvpwrvgnd_1
XFILLER_119_659 VGND VGND VPWR VPWR sky130_fd_sc_hd__decap_3
XFILLER_9_293 VGND VGND VPWR VPWR sky130_fd_sc_hd__fill_2
X_6452_ _6610_/A VGND VGND VPWR VPWR _6452_/Y sky130_fd_sc_hd__inv_2
XFILLER_118_136 VGND VGND VPWR VPWR sky130_fd_sc_hd__fill_1
XFILLER_109_18 VGND VGND VPWR VPWR sky130_fd_sc_hd__decap_3
Xclkload30 _7360_/CLK VGND VGND VPWR VPWR clkload30/Y sky130_fd_sc_hd__clkinv_4
XFILLER_106_309 VGND VGND VPWR VPWR sky130_fd_sc_hd__decap_3
X_3595_ _4292_/A _3594_/B _3594_/Y _5020_/A VGND VGND VPWR VPWR _3614_/A sky130_fd_sc_hd__a211o_2
X_6383_ _6612_/A VGND VGND VPWR VPWR _6383_/Y sky130_fd_sc_hd__inv_2
XFILLER_114_320 VGND VGND VPWR VPWR sky130_fd_sc_hd__decap_3
XFILLER_114_342 VGND VGND VPWR VPWR sky130_fd_sc_hd__decap_3
XFILLER_88_716 VGND VGND VPWR VPWR sky130_fd_sc_hd__decap_3
XFILLER_102_548 VGND VGND VPWR VPWR sky130_fd_sc_hd__decap_3
X_7004_ _7370_/CLK _7004_/D _6284_/Y VGND VGND VPWR VPWR _7004_/Q sky130_fd_sc_hd__dfrtp_2
XFILLER_87_248 VGND VGND VPWR VPWR sky130_fd_sc_hd__decap_3
X_4216_ _7068_/Q _4265_/B _4460_/A VGND VGND VPWR VPWR _4371_/B sky130_fd_sc_hd__o21a_2
X_5196_ _5196_/A _5207_/B VGND VGND VPWR VPWR _7230_/D sky130_fd_sc_hd__and2_2
XFILLER_68_451 VGND VGND VPWR VPWR sky130_fd_sc_hd__decap_3
XFILLER_56_613 VGND VGND VPWR VPWR sky130_fd_sc_hd__decap_3
XFILLER_28_304 VGND VGND VPWR VPWR sky130_fd_sc_hd__decap_3
X_4147_ _7266_/Q _4422_/A2 _3956_/S _7330_/Q _4146_/X VGND VGND VPWR VPWR _4147_/X
+ sky130_fd_sc_hd__a221o_2
XFILLER_28_315 VGND VGND VPWR VPWR sky130_fd_sc_hd__decap_3
XFILLER_68_495 VGND VGND VPWR VPWR sky130_fd_sc_hd__decap_3
XFILLER_110_581 VGND VGND VPWR VPWR sky130_fd_sc_hd__decap_3
XFILLER_110_592 VGND VGND VPWR VPWR sky130_fd_sc_hd__decap_3
XFILLER_56_657 VGND VGND VPWR VPWR sky130_fd_sc_hd__decap_3
XFILLER_28_348 VGND VGND VPWR VPWR sky130_fd_sc_hd__decap_3
X_4078_ _7025_/Q _4431_/A2 _4394_/B _7371_/Q VGND VGND VPWR VPWR _4078_/X sky130_fd_sc_hd__a22o_2
XFILLER_55_145 VGND VGND VPWR VPWR sky130_fd_sc_hd__fill_2
XFILLER_55_156 VGND VGND VPWR VPWR sky130_fd_sc_hd__fill_1
XFILLER_83_476 VGND VGND VPWR VPWR sky130_fd_sc_hd__decap_3
XFILLER_71_638 VGND VGND VPWR VPWR sky130_fd_sc_hd__decap_3
XTAP_TAPCELL_ROW_104_1614 VGND VPWR sky130_fd_sc_hd__tapvpwrvgnd_1
XTAP_TAPCELL_ROW_104_1625 VGND VPWR sky130_fd_sc_hd__tapvpwrvgnd_1
XFILLER_70_126 VGND VGND VPWR VPWR sky130_fd_sc_hd__fill_2
XFILLER_64_690 VGND VGND VPWR VPWR sky130_fd_sc_hd__decap_3
XFILLER_70_159 VGND VGND VPWR VPWR sky130_fd_sc_hd__decap_3
XFILLER_51_340 VGND VGND VPWR VPWR sky130_fd_sc_hd__fill_1
XFILLER_12_716 VGND VGND VPWR VPWR sky130_fd_sc_hd__decap_3
XFILLER_24_587 VGND VGND VPWR VPWR sky130_fd_sc_hd__fill_1
XFILLER_24_598 VGND VGND VPWR VPWR sky130_fd_sc_hd__decap_3
XTAP_TAPCELL_ROW_63_1090 VGND VPWR sky130_fd_sc_hd__tapvpwrvgnd_1
X_6719_ clkload8/A _6719_/D VGND VGND VPWR VPWR _6719_/Q sky130_fd_sc_hd__dfxtp_2
Xclkload2 clkload2/A VGND VGND VPWR VPWR clkload2/X sky130_fd_sc_hd__clkbuf_16
XFILLER_109_147 VGND VGND VPWR VPWR sky130_fd_sc_hd__fill_2
XFILLER_50_68 VGND VGND VPWR VPWR sky130_fd_sc_hd__decap_3
XFILLER_118_681 VGND VGND VPWR VPWR sky130_fd_sc_hd__decap_3
XFILLER_3_425 VGND VGND VPWR VPWR sky130_fd_sc_hd__decap_3
XTAP_TAPCELL_ROW_115_1765 VGND VPWR sky130_fd_sc_hd__tapvpwrvgnd_1
XFILLER_117_191 VGND VGND VPWR VPWR sky130_fd_sc_hd__decap_3
XFILLER_79_727 VGND VGND VPWR VPWR sky130_fd_sc_hd__fill_1
XFILLER_105_364 VGND VGND VPWR VPWR sky130_fd_sc_hd__decap_3
XFILLER_78_215 VGND VGND VPWR VPWR sky130_fd_sc_hd__decap_3
XFILLER_105_386 VGND VGND VPWR VPWR sky130_fd_sc_hd__decap_3
XFILLER_59_88 VGND VGND VPWR VPWR sky130_fd_sc_hd__decap_3
XFILLER_120_323 VGND VGND VPWR VPWR sky130_fd_sc_hd__decap_3
XFILLER_78_248 VGND VGND VPWR VPWR sky130_fd_sc_hd__decap_3
XFILLER_94_719 VGND VGND VPWR VPWR sky130_fd_sc_hd__decap_3
XFILLER_120_356 VGND VGND VPWR VPWR sky130_fd_sc_hd__fill_1
XFILLER_93_218 VGND VGND VPWR VPWR sky130_fd_sc_hd__decap_3
XFILLER_75_21 VGND VGND VPWR VPWR sky130_fd_sc_hd__decap_3
XFILLER_59_473 VGND VGND VPWR VPWR sky130_fd_sc_hd__decap_3
XFILLER_47_613 VGND VGND VPWR VPWR sky130_fd_sc_hd__decap_3
XFILLER_120_389 VGND VGND VPWR VPWR sky130_fd_sc_hd__decap_3
XFILLER_115_72 VGND VGND VPWR VPWR sky130_fd_sc_hd__decap_3
XFILLER_101_570 VGND VGND VPWR VPWR sky130_fd_sc_hd__decap_3
XFILLER_47_635 VGND VGND VPWR VPWR sky130_fd_sc_hd__decap_3
XFILLER_47_668 VGND VGND VPWR VPWR sky130_fd_sc_hd__decap_3
XFILLER_62_605 VGND VGND VPWR VPWR sky130_fd_sc_hd__decap_3
XFILLER_47_679 VGND VGND VPWR VPWR sky130_fd_sc_hd__decap_3
XFILLER_46_156 VGND VGND VPWR VPWR sky130_fd_sc_hd__fill_1
XTAP_TAPCELL_ROW_66_1119 VGND VPWR sky130_fd_sc_hd__tapvpwrvgnd_1
XFILLER_74_487 VGND VGND VPWR VPWR sky130_fd_sc_hd__decap_3
XFILLER_61_104 VGND VGND VPWR VPWR sky130_fd_sc_hd__decap_3
XFILLER_62_638 VGND VGND VPWR VPWR sky130_fd_sc_hd__decap_3
XFILLER_27_370 VGND VGND VPWR VPWR sky130_fd_sc_hd__decap_3
XTAP_TAPCELL_ROW_45_847 VGND VPWR sky130_fd_sc_hd__tapvpwrvgnd_1
XTAP_TAPCELL_ROW_45_858 VGND VPWR sky130_fd_sc_hd__tapvpwrvgnd_1
XFILLER_15_532 VGND VGND VPWR VPWR sky130_fd_sc_hd__decap_3
XFILLER_70_660 VGND VGND VPWR VPWR sky130_fd_sc_hd__decap_3
XFILLER_30_502 VGND VGND VPWR VPWR sky130_fd_sc_hd__decap_3
XFILLER_15_576 VGND VGND VPWR VPWR sky130_fd_sc_hd__decap_3
XFILLER_70_693 VGND VGND VPWR VPWR sky130_fd_sc_hd__decap_3
XTAP_TAPCELL_ROW_25_593 VGND VPWR sky130_fd_sc_hd__tapvpwrvgnd_1
XFILLER_116_607 VGND VGND VPWR VPWR sky130_fd_sc_hd__decap_3
XFILLER_10_292 VGND VGND VPWR VPWR sky130_fd_sc_hd__decap_3
Xhold709 _6888_/Q VGND VGND VPWR VPWR _6888_/D sky130_fd_sc_hd__dlygate4sd3_1
XFILLER_6_274 VGND VGND VPWR VPWR sky130_fd_sc_hd__fill_2
X_3380_ _3528_/A _5118_/D VGND VGND VPWR VPWR _3380_/Y sky130_fd_sc_hd__nor2_2
XFILLER_97_502 VGND VGND VPWR VPWR sky130_fd_sc_hd__fill_2
XTAP_TAPCELL_ROW_90_1437 VGND VPWR sky130_fd_sc_hd__tapvpwrvgnd_1
XFILLER_123_161 VGND VGND VPWR VPWR sky130_fd_sc_hd__decap_3
XFILLER_69_237 VGND VGND VPWR VPWR sky130_fd_sc_hd__decap_3
XFILLER_111_323 VGND VGND VPWR VPWR sky130_fd_sc_hd__decap_3
X_5050_ _5086_/A _5101_/B _5100_/B _4366_/X VGND VGND VPWR VPWR _5050_/X sky130_fd_sc_hd__a31o_2
XFILLER_97_579 VGND VGND VPWR VPWR sky130_fd_sc_hd__decap_3
XFILLER_27_3 VGND VGND VPWR VPWR sky130_fd_sc_hd__fill_2
XFILLER_111_356 VGND VGND VPWR VPWR sky130_fd_sc_hd__decap_3
XFILLER_38_613 VGND VGND VPWR VPWR sky130_fd_sc_hd__decap_3
XFILLER_84_229 VGND VGND VPWR VPWR sky130_fd_sc_hd__decap_3
XFILLER_65_410 VGND VGND VPWR VPWR sky130_fd_sc_hd__decap_3
XFILLER_77_281 VGND VGND VPWR VPWR sky130_fd_sc_hd__decap_3
XFILLER_65_443 VGND VGND VPWR VPWR sky130_fd_sc_hd__decap_3
XFILLER_38_657 VGND VGND VPWR VPWR sky130_fd_sc_hd__decap_3
XFILLER_1_51 VGND VGND VPWR VPWR sky130_fd_sc_hd__decap_3
XFILLER_92_262 VGND VGND VPWR VPWR sky130_fd_sc_hd__decap_3
XFILLER_65_476 VGND VGND VPWR VPWR sky130_fd_sc_hd__decap_3
XFILLER_53_638 VGND VGND VPWR VPWR sky130_fd_sc_hd__decap_3
XFILLER_80_435 VGND VGND VPWR VPWR sky130_fd_sc_hd__fill_2
XFILLER_46_690 VGND VGND VPWR VPWR sky130_fd_sc_hd__decap_3
X_4903_ _4903_/A _4903_/B _4903_/C VGND VGND VPWR VPWR _4903_/X sky130_fd_sc_hd__and3_2
XFILLER_33_340 VGND VGND VPWR VPWR sky130_fd_sc_hd__decap_3
XFILLER_61_671 VGND VGND VPWR VPWR sky130_fd_sc_hd__fill_1
XFILLER_61_682 VGND VGND VPWR VPWR sky130_fd_sc_hd__decap_3
X_4834_ _4834_/A _4834_/B VGND VGND VPWR VPWR _4834_/Y sky130_fd_sc_hd__nor2_2
XFILLER_21_535 VGND VGND VPWR VPWR sky130_fd_sc_hd__decap_3
XFILLER_60_192 VGND VGND VPWR VPWR sky130_fd_sc_hd__decap_3
X_4765_ _4788_/A _4765_/B VGND VGND VPWR VPWR _4766_/A sky130_fd_sc_hd__and2_2
X_6504_ _6504_/A VGND VGND VPWR VPWR _6504_/Y sky130_fd_sc_hd__inv_2
X_4696_ _5118_/C _4696_/B VGND VGND VPWR VPWR _5670_/B sky130_fd_sc_hd__nor2_2
XFILLER_119_478 VGND VGND VPWR VPWR sky130_fd_sc_hd__decap_3
XFILLER_107_629 VGND VGND VPWR VPWR sky130_fd_sc_hd__decap_3
X_6435_ _6596_/A VGND VGND VPWR VPWR _6435_/Y sky130_fd_sc_hd__inv_2
XFILLER_106_128 VGND VGND VPWR VPWR sky130_fd_sc_hd__decap_3
X_6366_ _6366_/A VGND VGND VPWR VPWR _6366_/Y sky130_fd_sc_hd__inv_2
X_3578_ _7284_/Q _5140_/S _3417_/X _7092_/Q VGND VGND VPWR VPWR _3583_/A sky130_fd_sc_hd__a22o_2
XFILLER_115_662 VGND VGND VPWR VPWR sky130_fd_sc_hd__decap_3
XFILLER_88_513 VGND VGND VPWR VPWR sky130_fd_sc_hd__decap_3
XFILLER_115_673 VGND VGND VPWR VPWR sky130_fd_sc_hd__decap_3
X_5317_ _5317_/A0 _4899_/X _5340_/S VGND VGND VPWR VPWR _7172_/D sky130_fd_sc_hd__mux2_2
XFILLER_114_161 VGND VGND VPWR VPWR sky130_fd_sc_hd__decap_3
XFILLER_102_301 VGND VGND VPWR VPWR sky130_fd_sc_hd__decap_3
X_6297_ _6387_/A VGND VGND VPWR VPWR _6297_/Y sky130_fd_sc_hd__inv_2
XFILLER_88_568 VGND VGND VPWR VPWR sky130_fd_sc_hd__decap_3
XFILLER_76_719 VGND VGND VPWR VPWR sky130_fd_sc_hd__decap_3
XFILLER_29_47 VGND VGND VPWR VPWR sky130_fd_sc_hd__fill_1
XFILLER_29_613 VGND VGND VPWR VPWR sky130_fd_sc_hd__decap_3
XTAP_TAPCELL_ROW_110_1695 VGND VPWR sky130_fd_sc_hd__tapvpwrvgnd_1
XFILLER_102_389 VGND VGND VPWR VPWR sky130_fd_sc_hd__decap_3
X_5179_ _5179_/A _5207_/B VGND VGND VPWR VPWR _7238_/D sky130_fd_sc_hd__and2_2
XFILLER_56_421 VGND VGND VPWR VPWR sky130_fd_sc_hd__decap_3
XFILLER_29_635 VGND VGND VPWR VPWR sky130_fd_sc_hd__decap_3
XFILLER_68_292 VGND VGND VPWR VPWR sky130_fd_sc_hd__decap_3
XFILLER_29_668 VGND VGND VPWR VPWR sky130_fd_sc_hd__decap_3
XFILLER_83_240 VGND VGND VPWR VPWR sky130_fd_sc_hd__decap_3
XFILLER_29_679 VGND VGND VPWR VPWR sky130_fd_sc_hd__decap_3
XFILLER_28_156 VGND VGND VPWR VPWR sky130_fd_sc_hd__decap_3
XFILLER_44_627 VGND VGND VPWR VPWR sky130_fd_sc_hd__decap_3
XFILLER_16_318 VGND VGND VPWR VPWR sky130_fd_sc_hd__decap_3
XFILLER_83_273 VGND VGND VPWR VPWR sky130_fd_sc_hd__decap_3
XFILLER_83_284 VGND VGND VPWR VPWR sky130_fd_sc_hd__decap_3
XFILLER_45_57 VGND VGND VPWR VPWR sky130_fd_sc_hd__decap_3
XFILLER_71_446 VGND VGND VPWR VPWR sky130_fd_sc_hd__fill_2
XFILLER_71_468 VGND VGND VPWR VPWR sky130_fd_sc_hd__decap_3
XFILLER_71_479 VGND VGND VPWR VPWR sky130_fd_sc_hd__decap_3
XFILLER_52_660 VGND VGND VPWR VPWR sky130_fd_sc_hd__decap_3
XFILLER_24_351 VGND VGND VPWR VPWR sky130_fd_sc_hd__decap_3
XTAP_TAPCELL_ROW_42_817 VGND VPWR sky130_fd_sc_hd__tapvpwrvgnd_1
XFILLER_52_693 VGND VGND VPWR VPWR sky130_fd_sc_hd__decap_3
XFILLER_12_524 VGND VGND VPWR VPWR sky130_fd_sc_hd__fill_2
XFILLER_101_85 VGND VGND VPWR VPWR sky130_fd_sc_hd__decap_3
XFILLER_12_568 VGND VGND VPWR VPWR sky130_fd_sc_hd__decap_3
XTAP_TAPCELL_ROW_22_552 VGND VPWR sky130_fd_sc_hd__tapvpwrvgnd_1
XFILLER_8_528 VGND VGND VPWR VPWR sky130_fd_sc_hd__decap_3
XFILLER_8_539 VGND VGND VPWR VPWR sky130_fd_sc_hd__decap_3
XFILLER_4_701 VGND VGND VPWR VPWR sky130_fd_sc_hd__decap_3
XFILLER_4_734 VGND VGND VPWR VPWR sky130_fd_sc_hd__fill_1
XFILLER_106_640 VGND VGND VPWR VPWR sky130_fd_sc_hd__decap_3
XFILLER_106_651 VGND VGND VPWR VPWR sky130_fd_sc_hd__decap_3
XFILLER_106_684 VGND VGND VPWR VPWR sky130_fd_sc_hd__decap_3
XFILLER_105_172 VGND VGND VPWR VPWR sky130_fd_sc_hd__decap_3
XFILLER_79_546 VGND VGND VPWR VPWR sky130_fd_sc_hd__decap_3
XFILLER_121_632 VGND VGND VPWR VPWR sky130_fd_sc_hd__decap_3
XFILLER_105_183 VGND VGND VPWR VPWR sky130_fd_sc_hd__decap_3
XFILLER_121_665 VGND VGND VPWR VPWR sky130_fd_sc_hd__decap_3
XFILLER_121_676 VGND VGND VPWR VPWR sky130_fd_sc_hd__decap_3
XFILLER_86_64 VGND VGND VPWR VPWR sky130_fd_sc_hd__decap_3
XFILLER_120_164 VGND VGND VPWR VPWR sky130_fd_sc_hd__decap_3
XFILLER_74_262 VGND VGND VPWR VPWR sky130_fd_sc_hd__decap_3
XFILLER_90_722 VGND VGND VPWR VPWR sky130_fd_sc_hd__decap_3
XFILLER_19_178 VGND VGND VPWR VPWR sky130_fd_sc_hd__decap_3
XFILLER_74_284 VGND VGND VPWR VPWR sky130_fd_sc_hd__decap_3
XFILLER_62_424 VGND VGND VPWR VPWR sky130_fd_sc_hd__decap_3
XFILLER_35_638 VGND VGND VPWR VPWR sky130_fd_sc_hd__decap_3
XFILLER_28_690 VGND VGND VPWR VPWR sky130_fd_sc_hd__decap_3
XFILLER_62_457 VGND VGND VPWR VPWR sky130_fd_sc_hd__decap_3
XFILLER_15_340 VGND VGND VPWR VPWR sky130_fd_sc_hd__decap_3
XFILLER_50_619 VGND VGND VPWR VPWR sky130_fd_sc_hd__decap_3
XFILLER_43_671 VGND VGND VPWR VPWR sky130_fd_sc_hd__fill_1
XFILLER_43_682 VGND VGND VPWR VPWR sky130_fd_sc_hd__decap_3
XFILLER_96_6 VGND VGND VPWR VPWR sky130_fd_sc_hd__decap_3
XFILLER_42_170 VGND VGND VPWR VPWR sky130_fd_sc_hd__decap_3
XFILLER_30_343 VGND VGND VPWR VPWR sky130_fd_sc_hd__decap_3
XFILLER_30_365 VGND VGND VPWR VPWR sky130_fd_sc_hd__decap_3
X_4550_ _7305_/Q _4559_/B VGND VGND VPWR VPWR _7305_/D sky130_fd_sc_hd__and2_2
XFILLER_116_404 VGND VGND VPWR VPWR sky130_fd_sc_hd__decap_3
X_3501_ _5144_/A _5144_/B _3500_/Y VGND VGND VPWR VPWR _3501_/X sky130_fd_sc_hd__a21o_2
XFILLER_7_561 VGND VGND VPWR VPWR sky130_fd_sc_hd__decap_3
XFILLER_7_594 VGND VGND VPWR VPWR sky130_fd_sc_hd__decap_3
XFILLER_103_109 VGND VGND VPWR VPWR sky130_fd_sc_hd__decap_3
X_3363_ _3386_/A _6983_/Q _6979_/Q VGND VGND VPWR VPWR _5294_/B sky130_fd_sc_hd__or3b_4
XFILLER_112_610 VGND VGND VPWR VPWR sky130_fd_sc_hd__decap_3
XFILLER_112_643 VGND VGND VPWR VPWR sky130_fd_sc_hd__fill_1
X_5102_ _5072_/A _4343_/X _5100_/Y _3618_/X _5101_/Y VGND VGND VPWR VPWR _5102_/X
+ sky130_fd_sc_hd__a221o_2
XFILLER_97_343 VGND VGND VPWR VPWR sky130_fd_sc_hd__decap_3
XFILLER_112_654 VGND VGND VPWR VPWR sky130_fd_sc_hd__decap_3
XFILLER_85_505 VGND VGND VPWR VPWR sky130_fd_sc_hd__decap_3
XFILLER_58_719 VGND VGND VPWR VPWR sky130_fd_sc_hd__decap_3
Xhold1206 _7296_/Q VGND VGND VPWR VPWR _4569_/A sky130_fd_sc_hd__dlygate4sd3_1
XFILLER_97_376 VGND VGND VPWR VPWR sky130_fd_sc_hd__decap_3
XFILLER_112_687 VGND VGND VPWR VPWR sky130_fd_sc_hd__decap_3
Xhold1217 _7223_/Q VGND VGND VPWR VPWR _5211_/A sky130_fd_sc_hd__dlygate4sd3_1
XFILLER_57_218 VGND VGND VPWR VPWR sky130_fd_sc_hd__decap_3
XFILLER_111_164 VGND VGND VPWR VPWR sky130_fd_sc_hd__decap_3
X_5033_ _5072_/A _4629_/Y _5032_/A _5033_/B2 VGND VGND VPWR VPWR _5033_/X sky130_fd_sc_hd__a22o_2
XFILLER_85_538 VGND VGND VPWR VPWR sky130_fd_sc_hd__decap_3
XFILLER_111_175 VGND VGND VPWR VPWR sky130_fd_sc_hd__decap_3
XFILLER_38_443 VGND VGND VPWR VPWR sky130_fd_sc_hd__decap_3
XFILLER_122_29 VGND VGND VPWR VPWR sky130_fd_sc_hd__decap_3
XFILLER_81_700 VGND VGND VPWR VPWR sky130_fd_sc_hd__decap_3
XFILLER_26_616 VGND VGND VPWR VPWR sky130_fd_sc_hd__decap_3
XFILLER_93_582 VGND VGND VPWR VPWR sky130_fd_sc_hd__decap_3
XFILLER_65_273 VGND VGND VPWR VPWR sky130_fd_sc_hd__decap_3
XFILLER_65_284 VGND VGND VPWR VPWR sky130_fd_sc_hd__decap_3
XTAP_TAPCELL_ROW_0_258 VGND VPWR sky130_fd_sc_hd__tapvpwrvgnd_1
X_6984_ clkload6/A _6984_/D _6264_/Y VGND VGND VPWR VPWR _6984_/Q sky130_fd_sc_hd__dfrtp_2
XFILLER_53_446 VGND VGND VPWR VPWR sky130_fd_sc_hd__fill_2
XTAP_TAPCELL_ROW_0_269 VGND VPWR sky130_fd_sc_hd__tapvpwrvgnd_1
XFILLER_80_243 VGND VGND VPWR VPWR sky130_fd_sc_hd__decap_3
XFILLER_53_479 VGND VGND VPWR VPWR sky130_fd_sc_hd__fill_1
XFILLER_80_265 VGND VGND VPWR VPWR sky130_fd_sc_hd__decap_3
XFILLER_34_660 VGND VGND VPWR VPWR sky130_fd_sc_hd__decap_3
XFILLER_80_298 VGND VGND VPWR VPWR sky130_fd_sc_hd__decap_3
XFILLER_34_693 VGND VGND VPWR VPWR sky130_fd_sc_hd__decap_3
XFILLER_33_181 VGND VGND VPWR VPWR sky130_fd_sc_hd__decap_3
X_4817_ _4810_/X _4811_/X _4815_/X _4816_/X VGND VGND VPWR VPWR _5663_/B sky130_fd_sc_hd__a211o_2
XFILLER_21_365 VGND VGND VPWR VPWR sky130_fd_sc_hd__decap_3
XFILLER_21_376 VGND VGND VPWR VPWR sky130_fd_sc_hd__decap_3
X_4748_ _3683_/Y _5664_/B _4791_/C1 VGND VGND VPWR VPWR _4751_/A sky130_fd_sc_hd__a21o_2
XFILLER_119_242 VGND VGND VPWR VPWR sky130_fd_sc_hd__decap_3
X_4679_ _6990_/Q _5014_/B VGND VGND VPWR VPWR _5015_/B sky130_fd_sc_hd__nand2_2
XFILLER_119_297 VGND VGND VPWR VPWR sky130_fd_sc_hd__decap_3
XPHY_EDGE_ROW_1_Right_1 VGND VGND VPWR VPWR sky130_fd_sc_hd__decap_3
X_6418_ _6610_/A VGND VGND VPWR VPWR _6418_/Y sky130_fd_sc_hd__inv_2
X_7398_ _7398_/CLK _7398_/D _6678_/Y VGND VGND VPWR VPWR _7398_/Q sky130_fd_sc_hd__dfrtp_2
XTAP_TAPCELL_ROW_112_1724 VGND VPWR sky130_fd_sc_hd__tapvpwrvgnd_1
XFILLER_0_203 VGND VGND VPWR VPWR sky130_fd_sc_hd__decap_3
XFILLER_1_726 VGND VGND VPWR VPWR sky130_fd_sc_hd__fill_2
XFILLER_115_470 VGND VGND VPWR VPWR sky130_fd_sc_hd__fill_1
X_6349_ _6667_/A VGND VGND VPWR VPWR _6349_/Y sky130_fd_sc_hd__inv_2
XFILLER_88_321 VGND VGND VPWR VPWR sky130_fd_sc_hd__fill_2
XFILLER_103_632 VGND VGND VPWR VPWR sky130_fd_sc_hd__decap_3
XFILLER_0_225 VGND VGND VPWR VPWR sky130_fd_sc_hd__decap_3
XTAP_TAPCELL_ROW_8_369 VGND VPWR sky130_fd_sc_hd__tapvpwrvgnd_1
XFILLER_103_665 VGND VGND VPWR VPWR sky130_fd_sc_hd__decap_3
XFILLER_88_365 VGND VGND VPWR VPWR sky130_fd_sc_hd__decap_3
XFILLER_103_676 VGND VGND VPWR VPWR sky130_fd_sc_hd__decap_3
XFILLER_88_398 VGND VGND VPWR VPWR sky130_fd_sc_hd__decap_3
XFILLER_48_229 VGND VGND VPWR VPWR sky130_fd_sc_hd__decap_3
XFILLER_102_197 VGND VGND VPWR VPWR sky130_fd_sc_hd__fill_1
XFILLER_56_251 VGND VGND VPWR VPWR sky130_fd_sc_hd__fill_1
XFILLER_56_78 VGND VGND VPWR VPWR sky130_fd_sc_hd__decap_3
XFILLER_56_262 VGND VGND VPWR VPWR sky130_fd_sc_hd__fill_2
XFILLER_72_722 VGND VGND VPWR VPWR sky130_fd_sc_hd__decap_3
XFILLER_17_638 VGND VGND VPWR VPWR sky130_fd_sc_hd__decap_3
XFILLER_71_210 VGND VGND VPWR VPWR sky130_fd_sc_hd__decap_3
XFILLER_44_424 VGND VGND VPWR VPWR sky130_fd_sc_hd__decap_3
XTAP_TAPCELL_ROW_27_622 VGND VPWR sky130_fd_sc_hd__tapvpwrvgnd_1
XFILLER_71_221 VGND VGND VPWR VPWR sky130_fd_sc_hd__decap_3
XFILLER_56_295 VGND VGND VPWR VPWR sky130_fd_sc_hd__decap_3
XFILLER_72_11 VGND VGND VPWR VPWR sky130_fd_sc_hd__decap_3
XFILLER_71_243 VGND VGND VPWR VPWR sky130_fd_sc_hd__decap_3
XFILLER_112_62 VGND VGND VPWR VPWR sky130_fd_sc_hd__decap_3
XFILLER_32_619 VGND VGND VPWR VPWR sky130_fd_sc_hd__decap_3
XFILLER_71_265 VGND VGND VPWR VPWR sky130_fd_sc_hd__decap_3
XTAP_TAPCELL_ROW_123_1864 VGND VPWR sky130_fd_sc_hd__tapvpwrvgnd_1
XTAP_TAPCELL_ROW_55_986 VGND VPWR sky130_fd_sc_hd__tapvpwrvgnd_1
XFILLER_25_671 VGND VGND VPWR VPWR sky130_fd_sc_hd__fill_1
XFILLER_112_95 VGND VGND VPWR VPWR sky130_fd_sc_hd__decap_3
XTAP_TAPCELL_ROW_123_1875 VGND VPWR sky130_fd_sc_hd__tapvpwrvgnd_1
XFILLER_71_287 VGND VGND VPWR VPWR sky130_fd_sc_hd__fill_1
XFILLER_25_682 VGND VGND VPWR VPWR sky130_fd_sc_hd__decap_3
XFILLER_52_490 VGND VGND VPWR VPWR sky130_fd_sc_hd__decap_3
XFILLER_24_192 VGND VGND VPWR VPWR sky130_fd_sc_hd__decap_3
XFILLER_12_343 VGND VGND VPWR VPWR sky130_fd_sc_hd__decap_3
XFILLER_40_663 VGND VGND VPWR VPWR sky130_fd_sc_hd__decap_3
XFILLER_8_336 VGND VGND VPWR VPWR sky130_fd_sc_hd__decap_3
XFILLER_40_696 VGND VGND VPWR VPWR sky130_fd_sc_hd__decap_3
XFILLER_12_398 VGND VGND VPWR VPWR sky130_fd_sc_hd__decap_3
XFILLER_4_531 VGND VGND VPWR VPWR sky130_fd_sc_hd__fill_1
XFILLER_4_542 VGND VGND VPWR VPWR sky130_fd_sc_hd__decap_3
XTAP_TAPCELL_ROW_74_1229 VGND VPWR sky130_fd_sc_hd__tapvpwrvgnd_1
XFILLER_113_418 VGND VGND VPWR VPWR sky130_fd_sc_hd__decap_3
XFILLER_98_118 VGND VGND VPWR VPWR sky130_fd_sc_hd__decap_3
XFILLER_4_575 VGND VGND VPWR VPWR sky130_fd_sc_hd__decap_3
XFILLER_106_470 VGND VGND VPWR VPWR sky130_fd_sc_hd__decap_3
XFILLER_79_321 VGND VGND VPWR VPWR sky130_fd_sc_hd__decap_3
XFILLER_97_85 VGND VGND VPWR VPWR sky130_fd_sc_hd__decap_3
XFILLER_67_505 VGND VGND VPWR VPWR sky130_fd_sc_hd__decap_3
XFILLER_39_218 VGND VGND VPWR VPWR sky130_fd_sc_hd__decap_3
XFILLER_121_473 VGND VGND VPWR VPWR sky130_fd_sc_hd__decap_3
XFILLER_94_368 VGND VGND VPWR VPWR sky130_fd_sc_hd__decap_3
XFILLER_63_700 VGND VGND VPWR VPWR sky130_fd_sc_hd__decap_3
XFILLER_35_402 VGND VGND VPWR VPWR sky130_fd_sc_hd__decap_3
XFILLER_47_273 VGND VGND VPWR VPWR sky130_fd_sc_hd__decap_3
XFILLER_47_284 VGND VGND VPWR VPWR sky130_fd_sc_hd__fill_1
XFILLER_47_295 VGND VGND VPWR VPWR sky130_fd_sc_hd__decap_3
XFILLER_62_232 VGND VGND VPWR VPWR sky130_fd_sc_hd__decap_3
XFILLER_35_457 VGND VGND VPWR VPWR sky130_fd_sc_hd__decap_3
XTAP_TAPCELL_ROW_85_1369 VGND VPWR sky130_fd_sc_hd__tapvpwrvgnd_1
XFILLER_90_563 VGND VGND VPWR VPWR sky130_fd_sc_hd__decap_3
XFILLER_50_405 VGND VGND VPWR VPWR sky130_fd_sc_hd__decap_3
XFILLER_35_479 VGND VGND VPWR VPWR sky130_fd_sc_hd__decap_3
X_3981_ _7350_/Q _4522_/A0 _3987_/S VGND VGND VPWR VPWR _7350_/D sky130_fd_sc_hd__mux2_2
XFILLER_16_660 VGND VGND VPWR VPWR sky130_fd_sc_hd__decap_3
XFILLER_50_427 VGND VGND VPWR VPWR sky130_fd_sc_hd__decap_3
XFILLER_62_298 VGND VGND VPWR VPWR sky130_fd_sc_hd__decap_3
XFILLER_16_693 VGND VGND VPWR VPWR sky130_fd_sc_hd__decap_3
Xclkbuf_leaf_42_clk clkbuf_leaf_1_clk/A VGND VGND VPWR VPWR _6978_/CLK sky130_fd_sc_hd__clkbuf_16
XFILLER_94_3 VGND VGND VPWR VPWR sky130_fd_sc_hd__decap_3
XFILLER_15_181 VGND VGND VPWR VPWR sky130_fd_sc_hd__decap_3
XFILLER_31_641 VGND VGND VPWR VPWR sky130_fd_sc_hd__decap_3
XFILLER_15_192 VGND VGND VPWR VPWR sky130_fd_sc_hd__decap_3
X_5651_ _5660_/C VGND VGND VPWR VPWR _5651_/Y sky130_fd_sc_hd__inv_2
XFILLER_30_151 VGND VGND VPWR VPWR sky130_fd_sc_hd__decap_3
XFILLER_31_685 VGND VGND VPWR VPWR sky130_fd_sc_hd__decap_3
XFILLER_30_184 VGND VGND VPWR VPWR sky130_fd_sc_hd__decap_3
X_7321_ _7354_/CLK _7321_/D _6601_/Y VGND VGND VPWR VPWR _7321_/Q sky130_fd_sc_hd__dfrtp_2
XFILLER_117_724 VGND VGND VPWR VPWR sky130_fd_sc_hd__decap_3
XFILLER_7_391 VGND VGND VPWR VPWR sky130_fd_sc_hd__fill_1
X_7252_ _7279_/CLK _7252_/D _6532_/Y VGND VGND VPWR VPWR _7252_/Q sky130_fd_sc_hd__dfrtp_2
XFILLER_117_18 VGND VGND VPWR VPWR sky130_fd_sc_hd__decap_3
X_4464_ _3541_/X _3610_/B _4463_/X VGND VGND VPWR VPWR _5655_/C sky130_fd_sc_hd__o21ai_2
XFILLER_104_418 VGND VGND VPWR VPWR sky130_fd_sc_hd__fill_2
XFILLER_116_289 VGND VGND VPWR VPWR sky130_fd_sc_hd__decap_3
X_3415_ _3449_/B _3449_/C _3417_/C VGND VGND VPWR VPWR _5159_/S sky130_fd_sc_hd__and3_4
X_7183_ clkload6/A _7183_/D _6463_/Y VGND VGND VPWR VPWR _7183_/Q sky130_fd_sc_hd__dfrtp_2
X_4395_ _4396_/A _4444_/B VGND VGND VPWR VPWR _4397_/A sky130_fd_sc_hd__and2_2
XFILLER_98_663 VGND VGND VPWR VPWR sky130_fd_sc_hd__decap_3
X_3346_ _3346_/A VGND VGND VPWR VPWR _3509_/B sky130_fd_sc_hd__inv_2
XFILLER_112_451 VGND VGND VPWR VPWR sky130_fd_sc_hd__decap_3
XTAP_TAPCELL_ROW_5_328 VGND VPWR sky130_fd_sc_hd__tapvpwrvgnd_1
XFILLER_85_302 VGND VGND VPWR VPWR sky130_fd_sc_hd__decap_3
XFILLER_58_527 VGND VGND VPWR VPWR sky130_fd_sc_hd__decap_3
XFILLER_100_613 VGND VGND VPWR VPWR sky130_fd_sc_hd__decap_3
Xhold1003 _7037_/Q VGND VGND VPWR VPWR _5583_/A0 sky130_fd_sc_hd__dlygate4sd3_1
XFILLER_98_696 VGND VGND VPWR VPWR sky130_fd_sc_hd__decap_3
Xhold1014 _7257_/Q VGND VGND VPWR VPWR _5080_/A0 sky130_fd_sc_hd__dlygate4sd3_1
XFILLER_85_335 VGND VGND VPWR VPWR sky130_fd_sc_hd__fill_1
Xhold1025 _7247_/Q VGND VGND VPWR VPWR _5159_/A0 sky130_fd_sc_hd__dlygate4sd3_1
Xhold1036 _7213_/Q VGND VGND VPWR VPWR _5234_/A0 sky130_fd_sc_hd__dlygate4sd3_1
XFILLER_100_657 VGND VGND VPWR VPWR sky130_fd_sc_hd__decap_3
Xhold1047 _7183_/Q VGND VGND VPWR VPWR _5292_/A0 sky130_fd_sc_hd__dlygate4sd3_1
XFILLER_85_357 VGND VGND VPWR VPWR sky130_fd_sc_hd__decap_3
X_5016_ _5032_/A _5031_/B _4629_/Y VGND VGND VPWR VPWR _5017_/B sky130_fd_sc_hd__a21oi_2
Xhold1058 _7251_/Q VGND VGND VPWR VPWR _5136_/A0 sky130_fd_sc_hd__dlygate4sd3_1
XFILLER_85_368 VGND VGND VPWR VPWR sky130_fd_sc_hd__decap_3
Xhold1069 _7384_/Q VGND VGND VPWR VPWR _3868_/A1 sky130_fd_sc_hd__dlygate4sd3_1
XFILLER_38_262 VGND VGND VPWR VPWR sky130_fd_sc_hd__decap_3
XFILLER_54_722 VGND VGND VPWR VPWR sky130_fd_sc_hd__decap_3
XFILLER_26_26 VGND VGND VPWR VPWR sky130_fd_sc_hd__fill_2
XFILLER_93_390 VGND VGND VPWR VPWR sky130_fd_sc_hd__fill_2
XFILLER_38_295 VGND VGND VPWR VPWR sky130_fd_sc_hd__decap_3
XFILLER_53_243 VGND VGND VPWR VPWR sky130_fd_sc_hd__decap_3
XFILLER_26_468 VGND VGND VPWR VPWR sky130_fd_sc_hd__decap_3
XFILLER_14_619 VGND VGND VPWR VPWR sky130_fd_sc_hd__decap_3
X_6967_ _6967_/CLK _6967_/D VGND VGND VPWR VPWR _6967_/Q sky130_fd_sc_hd__dfxtp_2
XFILLER_81_585 VGND VGND VPWR VPWR sky130_fd_sc_hd__decap_3
XFILLER_53_276 VGND VGND VPWR VPWR sky130_fd_sc_hd__decap_3
XFILLER_13_107 VGND VGND VPWR VPWR sky130_fd_sc_hd__decap_3
XFILLER_53_287 VGND VGND VPWR VPWR sky130_fd_sc_hd__decap_3
XTAP_TAPCELL_ROW_52_945 VGND VPWR sky130_fd_sc_hd__tapvpwrvgnd_1
X_6898_ clkload4/A _6898_/D VGND VGND VPWR VPWR _6898_/Q sky130_fd_sc_hd__dfxtp_2
Xclkbuf_leaf_33_clk clkbuf_leaf_2_clk/A VGND VGND VPWR VPWR _7313_/CLK sky130_fd_sc_hd__clkbuf_16
XFILLER_22_663 VGND VGND VPWR VPWR sky130_fd_sc_hd__decap_3
XFILLER_22_696 VGND VGND VPWR VPWR sky130_fd_sc_hd__decap_3
XTAP_TAPCELL_ROW_32_680 VGND VPWR sky130_fd_sc_hd__tapvpwrvgnd_1
XFILLER_108_713 VGND VGND VPWR VPWR sky130_fd_sc_hd__decap_3
XFILLER_123_716 VGND VGND VPWR VPWR sky130_fd_sc_hd__fill_1
XFILLER_107_267 VGND VGND VPWR VPWR sky130_fd_sc_hd__fill_2
Xhold870 _7069_/Q VGND VGND VPWR VPWR _7069_/D sky130_fd_sc_hd__dlygate4sd3_1
XFILLER_1_523 VGND VGND VPWR VPWR sky130_fd_sc_hd__decap_3
Xhold881 _7059_/Q VGND VGND VPWR VPWR _7059_/D sky130_fd_sc_hd__dlygate4sd3_1
XFILLER_89_641 VGND VGND VPWR VPWR sky130_fd_sc_hd__decap_3
XFILLER_107_40 VGND VGND VPWR VPWR sky130_fd_sc_hd__decap_3
Xhold892 _7080_/Q VGND VGND VPWR VPWR _7080_/D sky130_fd_sc_hd__dlygate4sd3_1
XFILLER_1_556 VGND VGND VPWR VPWR sky130_fd_sc_hd__decap_3
XFILLER_49_505 VGND VGND VPWR VPWR sky130_fd_sc_hd__decap_3
XFILLER_1_567 VGND VGND VPWR VPWR sky130_fd_sc_hd__decap_3
XFILLER_89_685 VGND VGND VPWR VPWR sky130_fd_sc_hd__decap_3
XFILLER_88_162 VGND VGND VPWR VPWR sky130_fd_sc_hd__decap_3
XFILLER_67_33 VGND VGND VPWR VPWR sky130_fd_sc_hd__decap_3
XFILLER_103_484 VGND VGND VPWR VPWR sky130_fd_sc_hd__decap_3
XFILLER_67_66 VGND VGND VPWR VPWR sky130_fd_sc_hd__decap_3
XFILLER_88_195 VGND VGND VPWR VPWR sky130_fd_sc_hd__fill_1
XFILLER_45_700 VGND VGND VPWR VPWR sky130_fd_sc_hd__decap_3
XFILLER_91_349 VGND VGND VPWR VPWR sky130_fd_sc_hd__decap_3
XFILLER_44_210 VGND VGND VPWR VPWR sky130_fd_sc_hd__decap_3
XFILLER_29_284 VGND VGND VPWR VPWR sky130_fd_sc_hd__decap_3
XFILLER_123_83 VGND VGND VPWR VPWR sky130_fd_sc_hd__fill_1
XFILLER_72_530 VGND VGND VPWR VPWR sky130_fd_sc_hd__fill_2
XFILLER_83_54 VGND VGND VPWR VPWR sky130_fd_sc_hd__fill_2
XFILLER_17_457 VGND VGND VPWR VPWR sky130_fd_sc_hd__fill_2
XFILLER_44_243 VGND VGND VPWR VPWR sky130_fd_sc_hd__decap_3
XFILLER_60_725 VGND VGND VPWR VPWR sky130_fd_sc_hd__decap_3
XFILLER_44_287 VGND VGND VPWR VPWR sky130_fd_sc_hd__decap_3
XFILLER_25_490 VGND VGND VPWR VPWR sky130_fd_sc_hd__fill_1
XFILLER_16_81 VGND VGND VPWR VPWR sky130_fd_sc_hd__decap_3
Xclkbuf_leaf_24_clk clkbuf_3_6__f_clk/X VGND VGND VPWR VPWR _7365_/CLK sky130_fd_sc_hd__clkbuf_16
XFILLER_13_641 VGND VGND VPWR VPWR sky130_fd_sc_hd__decap_3
XFILLER_9_612 VGND VGND VPWR VPWR sky130_fd_sc_hd__decap_3
XFILLER_9_623 VGND VGND VPWR VPWR sky130_fd_sc_hd__decap_3
XFILLER_8_100 VGND VGND VPWR VPWR sky130_fd_sc_hd__fill_2
XFILLER_13_685 VGND VGND VPWR VPWR sky130_fd_sc_hd__decap_3
XFILLER_40_471 VGND VGND VPWR VPWR sky130_fd_sc_hd__decap_3
XFILLER_12_162 VGND VGND VPWR VPWR sky130_fd_sc_hd__decap_3
XFILLER_8_122 VGND VGND VPWR VPWR sky130_fd_sc_hd__fill_1
XFILLER_9_656 VGND VGND VPWR VPWR sky130_fd_sc_hd__decap_3
XFILLER_12_195 VGND VGND VPWR VPWR sky130_fd_sc_hd__fill_1
XFILLER_8_166 VGND VGND VPWR VPWR sky130_fd_sc_hd__decap_3
XFILLER_8_188 VGND VGND VPWR VPWR sky130_fd_sc_hd__decap_3
XTAP_TAPCELL_ROW_10_396 VGND VPWR sky130_fd_sc_hd__tapvpwrvgnd_1
XFILLER_114_716 VGND VGND VPWR VPWR sky130_fd_sc_hd__decap_3
XFILLER_99_438 VGND VGND VPWR VPWR sky130_fd_sc_hd__decap_3
XFILLER_113_215 VGND VGND VPWR VPWR sky130_fd_sc_hd__fill_1
XFILLER_99_449 VGND VGND VPWR VPWR sky130_fd_sc_hd__decap_3
XFILLER_113_237 VGND VGND VPWR VPWR sky130_fd_sc_hd__decap_3
XFILLER_79_140 VGND VGND VPWR VPWR sky130_fd_sc_hd__decap_3
X_4180_ _7232_/Q _4353_/A2 _4244_/B _7045_/Q VGND VGND VPWR VPWR _4180_/X sky130_fd_sc_hd__a22o_2
XFILLER_95_600 VGND VGND VPWR VPWR sky130_fd_sc_hd__decap_3
XFILLER_67_313 VGND VGND VPWR VPWR sky130_fd_sc_hd__decap_3
XFILLER_95_644 VGND VGND VPWR VPWR sky130_fd_sc_hd__decap_3
XFILLER_94_121 VGND VGND VPWR VPWR sky130_fd_sc_hd__decap_3
XFILLER_121_292 VGND VGND VPWR VPWR sky130_fd_sc_hd__decap_3
XFILLER_67_357 VGND VGND VPWR VPWR sky130_fd_sc_hd__decap_3
XFILLER_55_508 VGND VGND VPWR VPWR sky130_fd_sc_hd__decap_3
XFILLER_67_368 VGND VGND VPWR VPWR sky130_fd_sc_hd__fill_1
XFILLER_95_688 VGND VGND VPWR VPWR sky130_fd_sc_hd__decap_3
XFILLER_36_722 VGND VGND VPWR VPWR sky130_fd_sc_hd__decap_3
XFILLER_35_210 VGND VGND VPWR VPWR sky130_fd_sc_hd__decap_3
XFILLER_35_243 VGND VGND VPWR VPWR sky130_fd_sc_hd__decap_3
X_6821_ clkload8/A _6821_/D VGND VGND VPWR VPWR _6821_/Q sky130_fd_sc_hd__dfxtp_2
XFILLER_51_703 VGND VGND VPWR VPWR sky130_fd_sc_hd__decap_3
XFILLER_90_371 VGND VGND VPWR VPWR sky130_fd_sc_hd__decap_3
XFILLER_35_287 VGND VGND VPWR VPWR sky130_fd_sc_hd__decap_3
XTAP_TAPCELL_ROW_18_496 VGND VPWR sky130_fd_sc_hd__tapvpwrvgnd_1
X_6752_ _6960_/CLK _6752_/D VGND VGND VPWR VPWR _6752_/Q sky130_fd_sc_hd__dfxtp_2
XFILLER_23_449 VGND VGND VPWR VPWR sky130_fd_sc_hd__decap_3
X_3964_ _3964_/A0 _4507_/A0 _3964_/S VGND VGND VPWR VPWR _7358_/D sky130_fd_sc_hd__mux2_2
Xclkbuf_leaf_15_clk clkload2/A VGND VGND VPWR VPWR _7399_/CLK sky130_fd_sc_hd__clkbuf_16
XFILLER_16_490 VGND VGND VPWR VPWR sky130_fd_sc_hd__decap_3
X_5703_ _7357_/Q hold920/X _5712_/S VGND VGND VPWR VPWR _6701_/D sky130_fd_sc_hd__mux2_2
XFILLER_50_268 VGND VGND VPWR VPWR sky130_fd_sc_hd__decap_3
X_6683_ _6685_/A VGND VGND VPWR VPWR _6683_/Y sky130_fd_sc_hd__inv_2
X_3895_ _3923_/A1 _3887_/X _3889_/X _3741_/X _3894_/X VGND VGND VPWR VPWR _3895_/X
+ sky130_fd_sc_hd__a221o_2
XFILLER_31_482 VGND VGND VPWR VPWR sky130_fd_sc_hd__decap_3
X_5634_ _5634_/A _5634_/B VGND VGND VPWR VPWR _7011_/D sky130_fd_sc_hd__and2_2
XTAP_TAPCELL_ROW_98_1538 VGND VPWR sky130_fd_sc_hd__tapvpwrvgnd_1
XFILLER_117_532 VGND VGND VPWR VPWR sky130_fd_sc_hd__decap_3
X_7304_ _7374_/CLK _7304_/D _6584_/Y VGND VGND VPWR VPWR _7304_/Q sky130_fd_sc_hd__dfrtp_2
XFILLER_2_309 VGND VGND VPWR VPWR sky130_fd_sc_hd__decap_3
XFILLER_117_576 VGND VGND VPWR VPWR sky130_fd_sc_hd__decap_3
XFILLER_105_727 VGND VGND VPWR VPWR sky130_fd_sc_hd__fill_1
X_7235_ _7374_/CLK _7235_/D _6515_/Y VGND VGND VPWR VPWR _7235_/Q sky130_fd_sc_hd__dfrtp_2
X_4447_ _4647_/C _4447_/B VGND VGND VPWR VPWR _4447_/Y sky130_fd_sc_hd__nor2_2
XFILLER_104_237 VGND VGND VPWR VPWR sky130_fd_sc_hd__decap_3
XFILLER_120_719 VGND VGND VPWR VPWR sky130_fd_sc_hd__decap_3
X_7166_ _7359_/CLK _7166_/D _6446_/Y VGND VGND VPWR VPWR _7166_/Q sky130_fd_sc_hd__dfrtp_2
X_4378_ _4243_/Y _4277_/Y _5032_/B _4377_/Y VGND VGND VPWR VPWR _4968_/A sky130_fd_sc_hd__a31o_4
XFILLER_98_460 VGND VGND VPWR VPWR sky130_fd_sc_hd__decap_3
XFILLER_86_622 VGND VGND VPWR VPWR sky130_fd_sc_hd__decap_3
X_3329_ _3340_/A _3340_/C VGND VGND VPWR VPWR _3329_/Y sky130_fd_sc_hd__nand2_2
XFILLER_100_421 VGND VGND VPWR VPWR sky130_fd_sc_hd__decap_3
X_7097_ _7356_/CLK _7097_/D _6377_/Y VGND VGND VPWR VPWR _7097_/Q sky130_fd_sc_hd__dfrtp_2
XFILLER_58_346 VGND VGND VPWR VPWR sky130_fd_sc_hd__decap_3
XFILLER_86_666 VGND VGND VPWR VPWR sky130_fd_sc_hd__decap_3
XFILLER_85_143 VGND VGND VPWR VPWR sky130_fd_sc_hd__decap_3
XFILLER_73_305 VGND VGND VPWR VPWR sky130_fd_sc_hd__decap_3
XFILLER_27_700 VGND VGND VPWR VPWR sky130_fd_sc_hd__decap_3
XFILLER_86_699 VGND VGND VPWR VPWR sky130_fd_sc_hd__fill_1
XFILLER_73_327 VGND VGND VPWR VPWR sky130_fd_sc_hd__decap_3
XFILLER_100_498 VGND VGND VPWR VPWR sky130_fd_sc_hd__decap_3
XFILLER_39_593 VGND VGND VPWR VPWR sky130_fd_sc_hd__decap_3
XFILLER_73_349 VGND VGND VPWR VPWR sky130_fd_sc_hd__decap_3
XFILLER_26_232 VGND VGND VPWR VPWR sky130_fd_sc_hd__decap_3
XTAP_TAPCELL_ROW_107_1656 VGND VPWR sky130_fd_sc_hd__tapvpwrvgnd_1
XTAP_TAPCELL_ROW_37_750 VGND VPWR sky130_fd_sc_hd__tapvpwrvgnd_1
XFILLER_42_725 VGND VGND VPWR VPWR sky130_fd_sc_hd__decap_3
XFILLER_41_202 VGND VGND VPWR VPWR sky130_fd_sc_hd__fill_1
XFILLER_14_416 VGND VGND VPWR VPWR sky130_fd_sc_hd__decap_3
XFILLER_14_427 VGND VGND VPWR VPWR sky130_fd_sc_hd__fill_2
XFILLER_26_298 VGND VGND VPWR VPWR sky130_fd_sc_hd__decap_3
XTAP_TAPCELL_ROW_120_1823 VGND VPWR sky130_fd_sc_hd__tapvpwrvgnd_1
XFILLER_81_393 VGND VGND VPWR VPWR sky130_fd_sc_hd__fill_1
XFILLER_53_57 VGND VGND VPWR VPWR sky130_fd_sc_hd__fill_2
XFILLER_41_257 VGND VGND VPWR VPWR sky130_fd_sc_hd__decap_3
XFILLER_10_622 VGND VGND VPWR VPWR sky130_fd_sc_hd__decap_3
XFILLER_6_604 VGND VGND VPWR VPWR sky130_fd_sc_hd__decap_3
XFILLER_10_666 VGND VGND VPWR VPWR sky130_fd_sc_hd__decap_3
XFILLER_5_103 VGND VGND VPWR VPWR sky130_fd_sc_hd__fill_1
XFILLER_108_510 VGND VGND VPWR VPWR sky130_fd_sc_hd__decap_3
XFILLER_6_637 VGND VGND VPWR VPWR sky130_fd_sc_hd__decap_3
XFILLER_6_648 VGND VGND VPWR VPWR sky130_fd_sc_hd__decap_3
XFILLER_10_699 VGND VGND VPWR VPWR sky130_fd_sc_hd__fill_1
XFILLER_108_554 VGND VGND VPWR VPWR sky130_fd_sc_hd__decap_3
XTAP_TAPCELL_ROW_118_1796 VGND VPWR sky130_fd_sc_hd__tapvpwrvgnd_1
XFILLER_123_513 VGND VGND VPWR VPWR sky130_fd_sc_hd__decap_3
XFILLER_118_50 VGND VGND VPWR VPWR sky130_fd_sc_hd__decap_3
XFILLER_108_587 VGND VGND VPWR VPWR sky130_fd_sc_hd__fill_1
XFILLER_108_598 VGND VGND VPWR VPWR sky130_fd_sc_hd__decap_3
XFILLER_118_83 VGND VGND VPWR VPWR sky130_fd_sc_hd__fill_1
XFILLER_78_32 VGND VGND VPWR VPWR sky130_fd_sc_hd__decap_3
XFILLER_123_557 VGND VGND VPWR VPWR sky130_fd_sc_hd__decap_3
XFILLER_118_94 VGND VGND VPWR VPWR sky130_fd_sc_hd__decap_3
XFILLER_78_54 VGND VGND VPWR VPWR sky130_fd_sc_hd__fill_1
XFILLER_77_600 VGND VGND VPWR VPWR sky130_fd_sc_hd__decap_3
XFILLER_49_302 VGND VGND VPWR VPWR sky130_fd_sc_hd__decap_3
XFILLER_89_482 VGND VGND VPWR VPWR sky130_fd_sc_hd__decap_3
XFILLER_77_644 VGND VGND VPWR VPWR sky130_fd_sc_hd__decap_3
XFILLER_49_335 VGND VGND VPWR VPWR sky130_fd_sc_hd__fill_1
XFILLER_37_508 VGND VGND VPWR VPWR sky130_fd_sc_hd__decap_3
XFILLER_77_688 VGND VGND VPWR VPWR sky130_fd_sc_hd__decap_3
XFILLER_37_519 VGND VGND VPWR VPWR sky130_fd_sc_hd__decap_3
XFILLER_92_625 VGND VGND VPWR VPWR sky130_fd_sc_hd__decap_3
XFILLER_94_64 VGND VGND VPWR VPWR sky130_fd_sc_hd__decap_3
XFILLER_91_113 VGND VGND VPWR VPWR sky130_fd_sc_hd__decap_3
XFILLER_18_722 VGND VGND VPWR VPWR sky130_fd_sc_hd__decap_3
XFILLER_17_221 VGND VGND VPWR VPWR sky130_fd_sc_hd__decap_3
XFILLER_94_97 VGND VGND VPWR VPWR sky130_fd_sc_hd__decap_3
XFILLER_92_669 VGND VGND VPWR VPWR sky130_fd_sc_hd__decap_3
XFILLER_91_146 VGND VGND VPWR VPWR sky130_fd_sc_hd__decap_3
XFILLER_45_552 VGND VGND VPWR VPWR sky130_fd_sc_hd__decap_3
XFILLER_17_243 VGND VGND VPWR VPWR sky130_fd_sc_hd__fill_2
XFILLER_33_703 VGND VGND VPWR VPWR sky130_fd_sc_hd__decap_3
XFILLER_60_511 VGND VGND VPWR VPWR sky130_fd_sc_hd__decap_3
XTAP_TAPCELL_ROW_82_1328 VGND VPWR sky130_fd_sc_hd__tapvpwrvgnd_1
XTAP_TAPCELL_ROW_82_1339 VGND VPWR sky130_fd_sc_hd__tapvpwrvgnd_1
XFILLER_32_213 VGND VGND VPWR VPWR sky130_fd_sc_hd__decap_3
XFILLER_72_393 VGND VGND VPWR VPWR sky130_fd_sc_hd__decap_3
XFILLER_60_533 VGND VGND VPWR VPWR sky130_fd_sc_hd__decap_3
XFILLER_32_246 VGND VGND VPWR VPWR sky130_fd_sc_hd__decap_3
XFILLER_20_408 VGND VGND VPWR VPWR sky130_fd_sc_hd__decap_3
XFILLER_60_577 VGND VGND VPWR VPWR sky130_fd_sc_hd__fill_1
XTAP_TAPCELL_ROW_15_466 VGND VPWR sky130_fd_sc_hd__tapvpwrvgnd_1
X_3680_ _3677_/Y _3906_/A2 _3759_/B1 _3679_/Y VGND VGND VPWR VPWR _3680_/X sky130_fd_sc_hd__a22o_2
XFILLER_9_464 VGND VGND VPWR VPWR sky130_fd_sc_hd__decap_3
XFILLER_118_329 VGND VGND VPWR VPWR sky130_fd_sc_hd__decap_3
X_5350_ _5350_/A0 _5131_/X _7412_/A VGND VGND VPWR VPWR _7156_/D sky130_fd_sc_hd__mux2_2
XFILLER_57_3 VGND VGND VPWR VPWR sky130_fd_sc_hd__decap_3
XFILLER_99_202 VGND VGND VPWR VPWR sky130_fd_sc_hd__fill_2
X_4301_ _7352_/Q _4346_/B1 _3366_/X _7160_/Q _4300_/X VGND VGND VPWR VPWR _4301_/X
+ sky130_fd_sc_hd__a221o_2
XTAP_TAPCELL_ROW_93_1479 VGND VPWR sky130_fd_sc_hd__tapvpwrvgnd_1
XFILLER_114_557 VGND VGND VPWR VPWR sky130_fd_sc_hd__decap_3
X_7020_ _7365_/CLK _7020_/D _6300_/Y VGND VGND VPWR VPWR _7020_/Q sky130_fd_sc_hd__dfrtp_2
XFILLER_99_268 VGND VGND VPWR VPWR sky130_fd_sc_hd__decap_3
X_4232_ _4228_/X _4231_/X _4327_/A VGND VGND VPWR VPWR _4628_/A sky130_fd_sc_hd__o21a_2
XFILLER_102_719 VGND VGND VPWR VPWR sky130_fd_sc_hd__decap_3
Xclkbuf_leaf_4_clk clkload0/A VGND VGND VPWR VPWR _6960_/CLK sky130_fd_sc_hd__clkbuf_16
XFILLER_68_622 VGND VGND VPWR VPWR sky130_fd_sc_hd__decap_3
X_4163_ _7073_/Q _4265_/B _4205_/A VGND VGND VPWR VPWR _4203_/B sky130_fd_sc_hd__o21a_2
XFILLER_95_441 VGND VGND VPWR VPWR sky130_fd_sc_hd__decap_3
XFILLER_68_666 VGND VGND VPWR VPWR sky130_fd_sc_hd__decap_3
XFILLER_83_603 VGND VGND VPWR VPWR sky130_fd_sc_hd__decap_3
XFILLER_67_154 VGND VGND VPWR VPWR sky130_fd_sc_hd__decap_3
X_4094_ _4095_/A _4210_/B VGND VGND VPWR VPWR _4096_/A sky130_fd_sc_hd__or2_2
XFILLER_68_699 VGND VGND VPWR VPWR sky130_fd_sc_hd__fill_1
XFILLER_55_316 VGND VGND VPWR VPWR sky130_fd_sc_hd__decap_3
XFILLER_83_647 VGND VGND VPWR VPWR sky130_fd_sc_hd__decap_3
XFILLER_67_198 VGND VGND VPWR VPWR sky130_fd_sc_hd__decap_3
XFILLER_82_179 VGND VGND VPWR VPWR sky130_fd_sc_hd__decap_3
XFILLER_24_725 VGND VGND VPWR VPWR sky130_fd_sc_hd__decap_3
XFILLER_91_691 VGND VGND VPWR VPWR sky130_fd_sc_hd__decap_3
X_6804_ _7403_/CLK _6804_/D VGND VGND VPWR VPWR _6804_/Q sky130_fd_sc_hd__dfxtp_2
XFILLER_51_533 VGND VGND VPWR VPWR sky130_fd_sc_hd__decap_3
Xplace360 _5080_/S VGND VGND VPWR VPWR _5028_/S sky130_fd_sc_hd__buf_2
XFILLER_23_235 VGND VGND VPWR VPWR sky130_fd_sc_hd__decap_3
Xplace371 _3556_/A VGND VGND VPWR VPWR _4248_/A sky130_fd_sc_hd__buf_2
X_4996_ _3860_/S _5657_/D _3817_/X _3346_/A VGND VGND VPWR VPWR _4996_/X sky130_fd_sc_hd__o211a_2
Xplace382 _3442_/A VGND VGND VPWR VPWR _3857_/A2 sky130_fd_sc_hd__buf_2
Xplace393 _5666_/A VGND VGND VPWR VPWR _4997_/A1 sky130_fd_sc_hd__buf_2
XFILLER_23_268 VGND VGND VPWR VPWR sky130_fd_sc_hd__decap_3
XFILLER_11_408 VGND VGND VPWR VPWR sky130_fd_sc_hd__decap_3
X_6735_ clkload4/A _6735_/D VGND VGND VPWR VPWR _6735_/Q sky130_fd_sc_hd__dfxtp_2
X_3947_ _7366_/Q _7334_/Q _3958_/S VGND VGND VPWR VPWR _7366_/D sky130_fd_sc_hd__mux2_2
XTAP_TAPCELL_ROW_102_1597 VGND VPWR sky130_fd_sc_hd__tapvpwrvgnd_1
X_6666_ _6672_/A VGND VGND VPWR VPWR _6666_/Y sky130_fd_sc_hd__inv_2
XFILLER_31_290 VGND VGND VPWR VPWR sky130_fd_sc_hd__decap_3
X_3878_ _6729_/Q _3878_/A2 _3878_/B1 _6741_/Q VGND VGND VPWR VPWR _3878_/X sky130_fd_sc_hd__a22o_2
XFILLER_109_318 VGND VGND VPWR VPWR sky130_fd_sc_hd__decap_3
X_5617_ _5617_/A _5634_/B VGND VGND VPWR VPWR _7019_/D sky130_fd_sc_hd__and2_2
X_6597_ _6598_/A VGND VGND VPWR VPWR _6597_/Y sky130_fd_sc_hd__inv_2
XFILLER_117_340 VGND VGND VPWR VPWR sky130_fd_sc_hd__decap_3
XTAP_TAPCELL_ROW_57_1010 VGND VPWR sky130_fd_sc_hd__tapvpwrvgnd_1
XFILLER_3_629 VGND VGND VPWR VPWR sky130_fd_sc_hd__decap_3
XFILLER_2_139 VGND VGND VPWR VPWR sky130_fd_sc_hd__fill_1
XFILLER_105_546 VGND VGND VPWR VPWR sky130_fd_sc_hd__decap_3
X_7218_ _7313_/CLK _7218_/D _6498_/Y VGND VGND VPWR VPWR _7218_/Q sky130_fd_sc_hd__dfrtp_2
XFILLER_105_579 VGND VGND VPWR VPWR sky130_fd_sc_hd__decap_3
XFILLER_120_516 VGND VGND VPWR VPWR sky130_fd_sc_hd__decap_3
X_7149_ _7406_/CLK _7149_/D _6429_/Y VGND VGND VPWR VPWR _7149_/Q sky130_fd_sc_hd__dfrtp_2
XFILLER_59_644 VGND VGND VPWR VPWR sky130_fd_sc_hd__decap_3
XFILLER_48_46 VGND VGND VPWR VPWR sky130_fd_sc_hd__decap_3
XFILLER_98_290 VGND VGND VPWR VPWR sky130_fd_sc_hd__decap_3
XFILLER_86_430 VGND VGND VPWR VPWR sky130_fd_sc_hd__decap_3
XPHY_EDGE_ROW_122_Right_122 VGND VGND VPWR VPWR sky130_fd_sc_hd__decap_3
XFILLER_19_508 VGND VGND VPWR VPWR sky130_fd_sc_hd__decap_3
XFILLER_59_688 VGND VGND VPWR VPWR sky130_fd_sc_hd__decap_3
XFILLER_100_251 VGND VGND VPWR VPWR sky130_fd_sc_hd__fill_1
XFILLER_74_625 VGND VGND VPWR VPWR sky130_fd_sc_hd__decap_3
XFILLER_100_262 VGND VGND VPWR VPWR sky130_fd_sc_hd__decap_3
XFILLER_86_485 VGND VGND VPWR VPWR sky130_fd_sc_hd__decap_3
XFILLER_58_176 VGND VGND VPWR VPWR sky130_fd_sc_hd__decap_3
XFILLER_73_113 VGND VGND VPWR VPWR sky130_fd_sc_hd__fill_2
XFILLER_46_327 VGND VGND VPWR VPWR sky130_fd_sc_hd__decap_3
XFILLER_100_295 VGND VGND VPWR VPWR sky130_fd_sc_hd__fill_2
XFILLER_74_669 VGND VGND VPWR VPWR sky130_fd_sc_hd__decap_3
XFILLER_73_146 VGND VGND VPWR VPWR sky130_fd_sc_hd__fill_2
XFILLER_104_85 VGND VGND VPWR VPWR sky130_fd_sc_hd__decap_3
XTAP_TAPCELL_ROW_68_1150 VGND VPWR sky130_fd_sc_hd__tapvpwrvgnd_1
XFILLER_15_703 VGND VGND VPWR VPWR sky130_fd_sc_hd__decap_3
XFILLER_42_522 VGND VGND VPWR VPWR sky130_fd_sc_hd__decap_3
XFILLER_27_596 VGND VGND VPWR VPWR sky130_fd_sc_hd__decap_3
XFILLER_54_393 VGND VGND VPWR VPWR sky130_fd_sc_hd__decap_3
XFILLER_42_544 VGND VGND VPWR VPWR sky130_fd_sc_hd__decap_3
XFILLER_14_246 VGND VGND VPWR VPWR sky130_fd_sc_hd__fill_1
XFILLER_42_577 VGND VGND VPWR VPWR sky130_fd_sc_hd__fill_2
XFILLER_120_62 VGND VGND VPWR VPWR sky130_fd_sc_hd__decap_3
XFILLER_30_728 VGND VGND VPWR VPWR sky130_fd_sc_hd__decap_3
Xfanout50 _6350_/A VGND VGND VPWR VPWR _6685_/A sky130_fd_sc_hd__buf_1
Xfanout61 _6616_/A VGND VGND VPWR VPWR _6520_/A sky130_fd_sc_hd__buf_1
XTAP_TAPCELL_ROW_12_425 VGND VPWR sky130_fd_sc_hd__tapvpwrvgnd_1
Xfanout72 _6558_/A VGND VGND VPWR VPWR _6619_/A sky130_fd_sc_hd__buf_2
XFILLER_80_88 VGND VGND VPWR VPWR sky130_fd_sc_hd__decap_3
XFILLER_13_60 VGND VGND VPWR VPWR sky130_fd_sc_hd__decap_3
XTAP_TAPCELL_ROW_40_789 VGND VPWR sky130_fd_sc_hd__tapvpwrvgnd_1
XTAP_TAPCELL_ROW_79_1290 VGND VPWR sky130_fd_sc_hd__tapvpwrvgnd_1
XFILLER_108_373 VGND VGND VPWR VPWR sky130_fd_sc_hd__decap_3
XFILLER_123_332 VGND VGND VPWR VPWR sky130_fd_sc_hd__decap_3
XFILLER_89_97 VGND VGND VPWR VPWR sky130_fd_sc_hd__decap_3
XFILLER_97_706 VGND VGND VPWR VPWR sky130_fd_sc_hd__decap_3
XFILLER_69_408 VGND VGND VPWR VPWR sky130_fd_sc_hd__decap_3
XFILLER_2_651 VGND VGND VPWR VPWR sky130_fd_sc_hd__decap_3
XFILLER_123_354 VGND VGND VPWR VPWR sky130_fd_sc_hd__fill_2
XFILLER_96_205 VGND VGND VPWR VPWR sky130_fd_sc_hd__decap_3
XFILLER_123_365 VGND VGND VPWR VPWR sky130_fd_sc_hd__decap_3
XFILLER_111_516 VGND VGND VPWR VPWR sky130_fd_sc_hd__decap_3
XFILLER_96_227 VGND VGND VPWR VPWR sky130_fd_sc_hd__decap_3
XFILLER_2_684 VGND VGND VPWR VPWR sky130_fd_sc_hd__decap_3
XFILLER_1_172 VGND VGND VPWR VPWR sky130_fd_sc_hd__fill_2
XFILLER_96_249 VGND VGND VPWR VPWR sky130_fd_sc_hd__decap_3
XFILLER_111_549 VGND VGND VPWR VPWR sky130_fd_sc_hd__decap_3
XFILLER_89_290 VGND VGND VPWR VPWR sky130_fd_sc_hd__decap_3
XFILLER_49_121 VGND VGND VPWR VPWR sky130_fd_sc_hd__decap_3
XFILLER_1_194 VGND VGND VPWR VPWR sky130_fd_sc_hd__decap_3
XFILLER_77_485 VGND VGND VPWR VPWR sky130_fd_sc_hd__decap_3
XFILLER_37_316 VGND VGND VPWR VPWR sky130_fd_sc_hd__decap_3
XFILLER_65_647 VGND VGND VPWR VPWR sky130_fd_sc_hd__decap_3
XFILLER_64_124 VGND VGND VPWR VPWR sky130_fd_sc_hd__decap_3
XFILLER_37_349 VGND VGND VPWR VPWR sky130_fd_sc_hd__decap_3
XFILLER_92_444 VGND VGND VPWR VPWR sky130_fd_sc_hd__decap_3
Xclkbuf_3_7__f_clk clkbuf_0_clk/X VGND VGND VPWR VPWR clkload3/A sky130_fd_sc_hd__clkbuf_16
XFILLER_92_477 VGND VGND VPWR VPWR sky130_fd_sc_hd__fill_1
XTAP_TAPCELL_ROW_48_889 VGND VPWR sky130_fd_sc_hd__tapvpwrvgnd_1
XFILLER_80_628 VGND VGND VPWR VPWR sky130_fd_sc_hd__decap_3
XFILLER_18_563 VGND VGND VPWR VPWR sky130_fd_sc_hd__decap_3
XFILLER_92_499 VGND VGND VPWR VPWR sky130_fd_sc_hd__decap_3
XFILLER_73_691 VGND VGND VPWR VPWR sky130_fd_sc_hd__decap_3
XFILLER_45_393 VGND VGND VPWR VPWR sky130_fd_sc_hd__decap_3
X_4850_ _4142_/X _4849_/Y _4633_/A VGND VGND VPWR VPWR _4850_/Y sky130_fd_sc_hd__o21ai_2
XFILLER_60_341 VGND VGND VPWR VPWR sky130_fd_sc_hd__decap_3
XFILLER_21_706 VGND VGND VPWR VPWR sky130_fd_sc_hd__decap_3
X_3801_ _3735_/X _3798_/X _3800_/X _3714_/X VGND VGND VPWR VPWR _3801_/X sky130_fd_sc_hd__a22o_2
XFILLER_60_374 VGND VGND VPWR VPWR sky130_fd_sc_hd__decap_3
X_4781_ _4444_/X _4780_/Y _4413_/A VGND VGND VPWR VPWR _4781_/X sky130_fd_sc_hd__o21a_2
XFILLER_33_599 VGND VGND VPWR VPWR sky130_fd_sc_hd__decap_3
X_6520_ _6520_/A VGND VGND VPWR VPWR _6520_/Y sky130_fd_sc_hd__inv_2
X_3732_ _6776_/Q _3884_/A2 _3913_/A2 _6764_/Q _3731_/X VGND VGND VPWR VPWR _3732_/X
+ sky130_fd_sc_hd__a221o_2
XFILLER_13_290 VGND VGND VPWR VPWR sky130_fd_sc_hd__decap_3
XFILLER_119_638 VGND VGND VPWR VPWR sky130_fd_sc_hd__decap_3
XFILLER_9_272 VGND VGND VPWR VPWR sky130_fd_sc_hd__decap_3
X_6451_ _6650_/A VGND VGND VPWR VPWR _6451_/Y sky130_fd_sc_hd__inv_2
XTAP_TAPCELL_ROW_95_1508 VGND VPWR sky130_fd_sc_hd__tapvpwrvgnd_1
Xclkload20 _7386_/CLK VGND VGND VPWR VPWR clkload20/Y sky130_fd_sc_hd__inv_4
X_5402_ _5402_/A0 _5027_/X _5427_/S VGND VGND VPWR VPWR _7132_/D sky130_fd_sc_hd__mux2_2
Xclkload31 _7362_/CLK VGND VGND VPWR VPWR clkload31/Y sky130_fd_sc_hd__bufinv_16
X_6382_ _6569_/A VGND VGND VPWR VPWR _6382_/Y sky130_fd_sc_hd__inv_2
X_3594_ _4292_/A _3594_/B VGND VGND VPWR VPWR _3594_/Y sky130_fd_sc_hd__nor2_2
X_5333_ _5333_/A0 _5027_/X _5340_/S VGND VGND VPWR VPWR _7164_/D sky130_fd_sc_hd__mux2_2
XFILLER_114_354 VGND VGND VPWR VPWR sky130_fd_sc_hd__decap_3
XFILLER_88_728 VGND VGND VPWR VPWR sky130_fd_sc_hd__decap_3
XFILLER_114_365 VGND VGND VPWR VPWR sky130_fd_sc_hd__decap_3
X_5264_ _5264_/A0 _4997_/X _5278_/S VGND VGND VPWR VPWR _7198_/D sky130_fd_sc_hd__mux2_2
X_7003_ _7370_/CLK _7003_/D _6283_/Y VGND VGND VPWR VPWR _7003_/Q sky130_fd_sc_hd__dfrtp_2
X_4215_ _7260_/Q _4356_/A2 _4212_/X _4214_/X VGND VGND VPWR VPWR _4371_/A sky130_fd_sc_hd__a211o_2
XFILLER_68_430 VGND VGND VPWR VPWR sky130_fd_sc_hd__decap_3
X_4146_ _7234_/Q _4421_/A2 _4348_/B1 _7138_/Q VGND VGND VPWR VPWR _4146_/X sky130_fd_sc_hd__a22o_2
XFILLER_95_260 VGND VGND VPWR VPWR sky130_fd_sc_hd__decap_3
XFILLER_110_560 VGND VGND VPWR VPWR sky130_fd_sc_hd__decap_3
XFILLER_56_625 VGND VGND VPWR VPWR sky130_fd_sc_hd__decap_3
XFILLER_55_102 VGND VGND VPWR VPWR sky130_fd_sc_hd__decap_3
XFILLER_28_327 VGND VGND VPWR VPWR sky130_fd_sc_hd__decap_3
XFILLER_55_113 VGND VGND VPWR VPWR sky130_fd_sc_hd__fill_1
XFILLER_95_293 VGND VGND VPWR VPWR sky130_fd_sc_hd__decap_3
XFILLER_83_433 VGND VGND VPWR VPWR sky130_fd_sc_hd__fill_2
X_4077_ _7243_/Q _4433_/B _4434_/A2 _7115_/Q _4076_/X VGND VGND VPWR VPWR _4077_/X
+ sky130_fd_sc_hd__a221o_2
XFILLER_83_455 VGND VGND VPWR VPWR sky130_fd_sc_hd__decap_3
XFILLER_56_669 VGND VGND VPWR VPWR sky130_fd_sc_hd__decap_3
XFILLER_71_617 VGND VGND VPWR VPWR sky130_fd_sc_hd__decap_3
XFILLER_43_319 VGND VGND VPWR VPWR sky130_fd_sc_hd__decap_3
XFILLER_36_360 VGND VGND VPWR VPWR sky130_fd_sc_hd__decap_3
XTAP_TAPCELL_ROW_104_1615 VGND VPWR sky130_fd_sc_hd__tapvpwrvgnd_1
XFILLER_36_371 VGND VGND VPWR VPWR sky130_fd_sc_hd__decap_3
XFILLER_24_533 VGND VGND VPWR VPWR sky130_fd_sc_hd__decap_3
XFILLER_63_190 VGND VGND VPWR VPWR sky130_fd_sc_hd__decap_3
XFILLER_24_566 VGND VGND VPWR VPWR sky130_fd_sc_hd__decap_3
XFILLER_12_728 VGND VGND VPWR VPWR sky130_fd_sc_hd__decap_3
X_4979_ _4979_/A0 _4978_/X _4979_/S VGND VGND VPWR VPWR _7263_/D sky130_fd_sc_hd__mux2_2
XFILLER_51_396 VGND VGND VPWR VPWR sky130_fd_sc_hd__decap_3
XTAP_TAPCELL_ROW_63_1080 VGND VPWR sky130_fd_sc_hd__tapvpwrvgnd_1
XTAP_TAPCELL_ROW_63_1091 VGND VPWR sky130_fd_sc_hd__tapvpwrvgnd_1
X_6718_ _6965_/CLK _6718_/D VGND VGND VPWR VPWR _6718_/Q sky130_fd_sc_hd__dfxtp_2
Xclkload3 clkload3/A VGND VGND VPWR VPWR clkload3/X sky130_fd_sc_hd__clkbuf_16
X_6649_ _6649_/A VGND VGND VPWR VPWR _6649_/Y sky130_fd_sc_hd__inv_2
XFILLER_50_47 VGND VGND VPWR VPWR sky130_fd_sc_hd__fill_1
XFILLER_118_660 VGND VGND VPWR VPWR sky130_fd_sc_hd__decap_3
XFILLER_3_404 VGND VGND VPWR VPWR sky130_fd_sc_hd__fill_1
XFILLER_118_693 VGND VGND VPWR VPWR sky130_fd_sc_hd__decap_3
XFILLER_3_437 VGND VGND VPWR VPWR sky130_fd_sc_hd__fill_1
XTAP_TAPCELL_ROW_115_1766 VGND VPWR sky130_fd_sc_hd__tapvpwrvgnd_1
XFILLER_79_706 VGND VGND VPWR VPWR sky130_fd_sc_hd__decap_3
XFILLER_105_343 VGND VGND VPWR VPWR sky130_fd_sc_hd__decap_3
XFILLER_120_302 VGND VGND VPWR VPWR sky130_fd_sc_hd__decap_3
XFILLER_105_376 VGND VGND VPWR VPWR sky130_fd_sc_hd__decap_3
XFILLER_78_227 VGND VGND VPWR VPWR sky130_fd_sc_hd__decap_3
XFILLER_115_40 VGND VGND VPWR VPWR sky130_fd_sc_hd__decap_3
XFILLER_59_452 VGND VGND VPWR VPWR sky130_fd_sc_hd__decap_3
XFILLER_120_368 VGND VGND VPWR VPWR sky130_fd_sc_hd__decap_3
XFILLER_19_316 VGND VGND VPWR VPWR sky130_fd_sc_hd__decap_3
XFILLER_86_271 VGND VGND VPWR VPWR sky130_fd_sc_hd__decap_3
XFILLER_46_102 VGND VGND VPWR VPWR sky130_fd_sc_hd__decap_3
XFILLER_115_84 VGND VGND VPWR VPWR sky130_fd_sc_hd__decap_3
XFILLER_101_582 VGND VGND VPWR VPWR sky130_fd_sc_hd__decap_3
XFILLER_47_647 VGND VGND VPWR VPWR sky130_fd_sc_hd__decap_3
XFILLER_75_66 VGND VGND VPWR VPWR sky130_fd_sc_hd__decap_3
XFILLER_75_77 VGND VGND VPWR VPWR sky130_fd_sc_hd__fill_2
XFILLER_75_88 VGND VGND VPWR VPWR sky130_fd_sc_hd__decap_3
XFILLER_74_466 VGND VGND VPWR VPWR sky130_fd_sc_hd__fill_1
XFILLER_74_477 VGND VGND VPWR VPWR sky130_fd_sc_hd__fill_2
XFILLER_62_617 VGND VGND VPWR VPWR sky130_fd_sc_hd__decap_3
XFILLER_15_511 VGND VGND VPWR VPWR sky130_fd_sc_hd__decap_3
XTAP_TAPCELL_ROW_45_848 VGND VPWR sky130_fd_sc_hd__tapvpwrvgnd_1
XFILLER_61_127 VGND VGND VPWR VPWR sky130_fd_sc_hd__decap_3
XFILLER_55_691 VGND VGND VPWR VPWR sky130_fd_sc_hd__decap_3
XFILLER_27_382 VGND VGND VPWR VPWR sky130_fd_sc_hd__decap_3
XFILLER_27_393 VGND VGND VPWR VPWR sky130_fd_sc_hd__decap_3
XFILLER_15_544 VGND VGND VPWR VPWR sky130_fd_sc_hd__decap_3
XFILLER_91_32 VGND VGND VPWR VPWR sky130_fd_sc_hd__fill_2
XFILLER_54_190 VGND VGND VPWR VPWR sky130_fd_sc_hd__decap_3
XFILLER_91_54 VGND VGND VPWR VPWR sky130_fd_sc_hd__fill_2
XFILLER_70_672 VGND VGND VPWR VPWR sky130_fd_sc_hd__decap_3
XFILLER_15_588 VGND VGND VPWR VPWR sky130_fd_sc_hd__decap_3
XFILLER_91_87 VGND VGND VPWR VPWR sky130_fd_sc_hd__decap_3
XFILLER_30_536 VGND VGND VPWR VPWR sky130_fd_sc_hd__decap_3
XTAP_TAPCELL_ROW_25_594 VGND VPWR sky130_fd_sc_hd__tapvpwrvgnd_1
XFILLER_24_70 VGND VGND VPWR VPWR sky130_fd_sc_hd__decap_3
XFILLER_30_569 VGND VGND VPWR VPWR sky130_fd_sc_hd__decap_3
XFILLER_7_721 VGND VGND VPWR VPWR sky130_fd_sc_hd__decap_3
XFILLER_7_732 VGND VGND VPWR VPWR sky130_fd_sc_hd__decap_3
XFILLER_116_619 VGND VGND VPWR VPWR sky130_fd_sc_hd__decap_3
XFILLER_6_253 VGND VGND VPWR VPWR sky130_fd_sc_hd__decap_3
XFILLER_109_671 VGND VGND VPWR VPWR sky130_fd_sc_hd__fill_1
XFILLER_109_682 VGND VGND VPWR VPWR sky130_fd_sc_hd__decap_3
XFILLER_6_286 VGND VGND VPWR VPWR sky130_fd_sc_hd__decap_3
XFILLER_69_205 VGND VGND VPWR VPWR sky130_fd_sc_hd__decap_3
XTAP_TAPCELL_ROW_90_1438 VGND VPWR sky130_fd_sc_hd__tapvpwrvgnd_1
XFILLER_111_302 VGND VGND VPWR VPWR sky130_fd_sc_hd__decap_3
XFILLER_69_216 VGND VGND VPWR VPWR sky130_fd_sc_hd__decap_3
XFILLER_97_547 VGND VGND VPWR VPWR sky130_fd_sc_hd__decap_3
XFILLER_69_249 VGND VGND VPWR VPWR sky130_fd_sc_hd__decap_3
XFILLER_111_335 VGND VGND VPWR VPWR sky130_fd_sc_hd__fill_1
XFILLER_85_709 VGND VGND VPWR VPWR sky130_fd_sc_hd__decap_3
XFILLER_77_271 VGND VGND VPWR VPWR sky130_fd_sc_hd__decap_3
XFILLER_38_625 VGND VGND VPWR VPWR sky130_fd_sc_hd__decap_3
XFILLER_65_422 VGND VGND VPWR VPWR sky130_fd_sc_hd__decap_3
XFILLER_77_293 VGND VGND VPWR VPWR sky130_fd_sc_hd__decap_3
XFILLER_38_669 VGND VGND VPWR VPWR sky130_fd_sc_hd__decap_3
XFILLER_92_241 VGND VGND VPWR VPWR sky130_fd_sc_hd__decap_3
XFILLER_65_455 VGND VGND VPWR VPWR sky130_fd_sc_hd__fill_1
XFILLER_53_606 VGND VGND VPWR VPWR sky130_fd_sc_hd__decap_3
XFILLER_53_617 VGND VGND VPWR VPWR sky130_fd_sc_hd__decap_3
XFILLER_80_403 VGND VGND VPWR VPWR sky130_fd_sc_hd__decap_3
XFILLER_92_274 VGND VGND VPWR VPWR sky130_fd_sc_hd__decap_3
XFILLER_18_371 VGND VGND VPWR VPWR sky130_fd_sc_hd__fill_2
XFILLER_52_127 VGND VGND VPWR VPWR sky130_fd_sc_hd__fill_2
XFILLER_52_138 VGND VGND VPWR VPWR sky130_fd_sc_hd__fill_2
XFILLER_18_382 VGND VGND VPWR VPWR sky130_fd_sc_hd__decap_3
XFILLER_45_190 VGND VGND VPWR VPWR sky130_fd_sc_hd__decap_3
XFILLER_61_650 VGND VGND VPWR VPWR sky130_fd_sc_hd__decap_3
XFILLER_33_352 VGND VGND VPWR VPWR sky130_fd_sc_hd__decap_3
X_4833_ _7001_/Q _4687_/B _5015_/A VGND VGND VPWR VPWR _4834_/B sky130_fd_sc_hd__o21ai_2
XFILLER_61_694 VGND VGND VPWR VPWR sky130_fd_sc_hd__decap_3
XFILLER_60_171 VGND VGND VPWR VPWR sky130_fd_sc_hd__decap_3
X_4764_ _4938_/A _4764_/B VGND VGND VPWR VPWR _4764_/Y sky130_fd_sc_hd__nor2_2
XFILLER_119_402 VGND VGND VPWR VPWR sky130_fd_sc_hd__decap_3
X_6503_ _6504_/A VGND VGND VPWR VPWR _6503_/Y sky130_fd_sc_hd__inv_2
XFILLER_119_424 VGND VGND VPWR VPWR sky130_fd_sc_hd__decap_3
XFILLER_119_435 VGND VGND VPWR VPWR sky130_fd_sc_hd__decap_3
X_4695_ _7008_/Q _4728_/A _4694_/Y _4909_/A VGND VGND VPWR VPWR _4695_/X sky130_fd_sc_hd__a211o_2
XFILLER_119_457 VGND VGND VPWR VPWR sky130_fd_sc_hd__decap_3
X_6434_ _6602_/A VGND VGND VPWR VPWR _6434_/Y sky130_fd_sc_hd__inv_2
X_6365_ _6366_/A VGND VGND VPWR VPWR _6365_/Y sky130_fd_sc_hd__inv_2
X_3577_ _7060_/Q _4305_/B VGND VGND VPWR VPWR _3591_/C sky130_fd_sc_hd__nor2_2
XFILLER_115_641 VGND VGND VPWR VPWR sky130_fd_sc_hd__decap_3
XFILLER_115_685 VGND VGND VPWR VPWR sky130_fd_sc_hd__decap_3
X_6296_ _6608_/A VGND VGND VPWR VPWR _6296_/Y sky130_fd_sc_hd__inv_2
XFILLER_88_525 VGND VGND VPWR VPWR sky130_fd_sc_hd__fill_2
XFILLER_88_536 VGND VGND VPWR VPWR sky130_fd_sc_hd__fill_1
XFILLER_114_173 VGND VGND VPWR VPWR sky130_fd_sc_hd__decap_3
XFILLER_102_313 VGND VGND VPWR VPWR sky130_fd_sc_hd__decap_3
XFILLER_88_547 VGND VGND VPWR VPWR sky130_fd_sc_hd__decap_3
X_5247_ hold992/X _4864_/X _5278_/S VGND VGND VPWR VPWR _7206_/D sky130_fd_sc_hd__mux2_2
XFILLER_29_26 VGND VGND VPWR VPWR sky130_fd_sc_hd__decap_3
XFILLER_102_368 VGND VGND VPWR VPWR sky130_fd_sc_hd__decap_3
XTAP_TAPCELL_ROW_110_1696 VGND VPWR sky130_fd_sc_hd__tapvpwrvgnd_1
XFILLER_56_411 VGND VGND VPWR VPWR sky130_fd_sc_hd__decap_3
XFILLER_68_271 VGND VGND VPWR VPWR sky130_fd_sc_hd__decap_3
XFILLER_84_731 VGND VGND VPWR VPWR sky130_fd_sc_hd__decap_3
XFILLER_29_647 VGND VGND VPWR VPWR sky130_fd_sc_hd__decap_3
XFILLER_56_433 VGND VGND VPWR VPWR sky130_fd_sc_hd__decap_3
X_4129_ _7299_/Q _4497_/S _4399_/A2 _7363_/Q _4347_/C1 VGND VGND VPWR VPWR _4129_/X
+ sky130_fd_sc_hd__a221o_2
XFILLER_56_466 VGND VGND VPWR VPWR sky130_fd_sc_hd__decap_3
XFILLER_83_252 VGND VGND VPWR VPWR sky130_fd_sc_hd__decap_3
XFILLER_56_477 VGND VGND VPWR VPWR sky130_fd_sc_hd__decap_3
XFILLER_71_414 VGND VGND VPWR VPWR sky130_fd_sc_hd__decap_3
XFILLER_44_639 VGND VGND VPWR VPWR sky130_fd_sc_hd__decap_3
XFILLER_43_116 VGND VGND VPWR VPWR sky130_fd_sc_hd__decap_3
XFILLER_37_691 VGND VGND VPWR VPWR sky130_fd_sc_hd__decap_3
XTAP_TAPCELL_ROW_42_807 VGND VPWR sky130_fd_sc_hd__tapvpwrvgnd_1
XTAP_TAPCELL_ROW_42_818 VGND VPWR sky130_fd_sc_hd__tapvpwrvgnd_1
XFILLER_52_672 VGND VGND VPWR VPWR sky130_fd_sc_hd__decap_3
XFILLER_24_363 VGND VGND VPWR VPWR sky130_fd_sc_hd__fill_1
XFILLER_12_547 VGND VGND VPWR VPWR sky130_fd_sc_hd__decap_3
XFILLER_8_507 VGND VGND VPWR VPWR sky130_fd_sc_hd__decap_3
XFILLER_101_97 VGND VGND VPWR VPWR sky130_fd_sc_hd__decap_3
XFILLER_61_57 VGND VGND VPWR VPWR sky130_fd_sc_hd__fill_2
XTAP_TAPCELL_ROW_22_553 VGND VPWR sky130_fd_sc_hd__tapvpwrvgnd_1
XFILLER_4_713 VGND VGND VPWR VPWR sky130_fd_sc_hd__decap_3
XFILLER_3_212 VGND VGND VPWR VPWR sky130_fd_sc_hd__decap_3
XFILLER_3_234 VGND VGND VPWR VPWR sky130_fd_sc_hd__decap_3
XTAP_TAPCELL_ROW_76_1260 VGND VPWR sky130_fd_sc_hd__tapvpwrvgnd_1
XFILLER_3_245 VGND VGND VPWR VPWR sky130_fd_sc_hd__decap_3
XFILLER_106_663 VGND VGND VPWR VPWR sky130_fd_sc_hd__decap_3
XFILLER_79_503 VGND VGND VPWR VPWR sky130_fd_sc_hd__fill_1
XFILLER_121_600 VGND VGND VPWR VPWR sky130_fd_sc_hd__decap_3
XFILLER_3_278 VGND VGND VPWR VPWR sky130_fd_sc_hd__fill_2
XFILLER_106_696 VGND VGND VPWR VPWR sky130_fd_sc_hd__decap_3
XFILLER_79_558 VGND VGND VPWR VPWR sky130_fd_sc_hd__fill_2
XFILLER_121_644 VGND VGND VPWR VPWR sky130_fd_sc_hd__decap_3
XFILLER_105_195 VGND VGND VPWR VPWR sky130_fd_sc_hd__decap_3
XFILLER_86_32 VGND VGND VPWR VPWR sky130_fd_sc_hd__decap_3
XFILLER_67_709 VGND VGND VPWR VPWR sky130_fd_sc_hd__decap_3
XFILLER_121_688 VGND VGND VPWR VPWR sky130_fd_sc_hd__decap_3
XFILLER_94_528 VGND VGND VPWR VPWR sky130_fd_sc_hd__decap_3
XFILLER_66_219 VGND VGND VPWR VPWR sky130_fd_sc_hd__decap_3
XFILLER_47_411 VGND VGND VPWR VPWR sky130_fd_sc_hd__fill_1
XFILLER_87_591 VGND VGND VPWR VPWR sky130_fd_sc_hd__decap_3
XFILLER_19_113 VGND VGND VPWR VPWR sky130_fd_sc_hd__decap_3
XFILLER_19_70 VGND VGND VPWR VPWR sky130_fd_sc_hd__decap_3
XFILLER_90_701 VGND VGND VPWR VPWR sky130_fd_sc_hd__decap_3
XFILLER_35_606 VGND VGND VPWR VPWR sky130_fd_sc_hd__decap_3
XFILLER_62_403 VGND VGND VPWR VPWR sky130_fd_sc_hd__decap_3
XFILLER_35_617 VGND VGND VPWR VPWR sky130_fd_sc_hd__decap_3
XFILLER_47_488 VGND VGND VPWR VPWR sky130_fd_sc_hd__decap_3
XFILLER_90_734 VGND VGND VPWR VPWR sky130_fd_sc_hd__fill_1
XFILLER_74_296 VGND VGND VPWR VPWR sky130_fd_sc_hd__decap_3
XFILLER_62_436 VGND VGND VPWR VPWR sky130_fd_sc_hd__decap_3
XFILLER_34_127 VGND VGND VPWR VPWR sky130_fd_sc_hd__decap_3
XFILLER_62_469 VGND VGND VPWR VPWR sky130_fd_sc_hd__decap_3
XFILLER_27_190 VGND VGND VPWR VPWR sky130_fd_sc_hd__decap_3
XFILLER_15_330 VGND VGND VPWR VPWR sky130_fd_sc_hd__decap_3
XFILLER_43_650 VGND VGND VPWR VPWR sky130_fd_sc_hd__decap_3
XFILLER_35_91 VGND VGND VPWR VPWR sky130_fd_sc_hd__fill_2
XFILLER_70_480 VGND VGND VPWR VPWR sky130_fd_sc_hd__decap_3
XFILLER_43_694 VGND VGND VPWR VPWR sky130_fd_sc_hd__decap_3
XFILLER_42_182 VGND VGND VPWR VPWR sky130_fd_sc_hd__decap_3
XFILLER_15_396 VGND VGND VPWR VPWR sky130_fd_sc_hd__decap_3
XFILLER_89_6 VGND VGND VPWR VPWR sky130_fd_sc_hd__decap_3
XFILLER_30_355 VGND VGND VPWR VPWR sky130_fd_sc_hd__decap_3
XFILLER_30_377 VGND VGND VPWR VPWR sky130_fd_sc_hd__decap_3
XFILLER_11_591 VGND VGND VPWR VPWR sky130_fd_sc_hd__decap_3
X_3500_ _4460_/A _4460_/B _3541_/B VGND VGND VPWR VPWR _3500_/Y sky130_fd_sc_hd__a21oi_2
XFILLER_7_551 VGND VGND VPWR VPWR sky130_fd_sc_hd__decap_3
X_4480_ _4480_/A0 _7307_/Q _4488_/S VGND VGND VPWR VPWR _7339_/D sky130_fd_sc_hd__mux2_2
XFILLER_7_573 VGND VGND VPWR VPWR sky130_fd_sc_hd__decap_3
XFILLER_116_416 VGND VGND VPWR VPWR sky130_fd_sc_hd__decap_3
XFILLER_116_427 VGND VGND VPWR VPWR sky130_fd_sc_hd__fill_2
X_3362_ _6979_/Q _6983_/Q _3386_/A VGND VGND VPWR VPWR _3362_/X sky130_fd_sc_hd__or3b_2
XFILLER_97_311 VGND VGND VPWR VPWR sky130_fd_sc_hd__decap_3
XFILLER_112_622 VGND VGND VPWR VPWR sky130_fd_sc_hd__decap_3
X_5101_ _5101_/A _5101_/B VGND VGND VPWR VPWR _5101_/Y sky130_fd_sc_hd__nor2_2
XPHY_EDGE_ROW_29_Left_153 VGND VGND VPWR VPWR sky130_fd_sc_hd__decap_3
XFILLER_97_355 VGND VGND VPWR VPWR sky130_fd_sc_hd__decap_3
XFILLER_112_666 VGND VGND VPWR VPWR sky130_fd_sc_hd__decap_3
Xhold1207 _7300_/Q VGND VGND VPWR VPWR _4561_/A sky130_fd_sc_hd__dlygate4sd3_1
X_5032_ _5032_/A _5032_/B VGND VGND VPWR VPWR _5032_/Y sky130_fd_sc_hd__xnor2_2
Xhold1218 _7287_/Q VGND VGND VPWR VPWR _4587_/A sky130_fd_sc_hd__dlygate4sd3_1
XFILLER_112_699 VGND VGND VPWR VPWR sky130_fd_sc_hd__fill_1
XFILLER_66_731 VGND VGND VPWR VPWR sky130_fd_sc_hd__decap_3
XFILLER_111_187 VGND VGND VPWR VPWR sky130_fd_sc_hd__decap_3
XFILLER_38_433 VGND VGND VPWR VPWR sky130_fd_sc_hd__decap_3
XFILLER_93_550 VGND VGND VPWR VPWR sky130_fd_sc_hd__decap_3
XFILLER_93_561 VGND VGND VPWR VPWR sky130_fd_sc_hd__decap_3
XFILLER_65_252 VGND VGND VPWR VPWR sky130_fd_sc_hd__decap_3
XFILLER_81_712 VGND VGND VPWR VPWR sky130_fd_sc_hd__decap_3
XFILLER_26_628 VGND VGND VPWR VPWR sky130_fd_sc_hd__decap_3
XFILLER_80_200 VGND VGND VPWR VPWR sky130_fd_sc_hd__decap_3
XFILLER_93_594 VGND VGND VPWR VPWR sky130_fd_sc_hd__decap_3
XTAP_TAPCELL_ROW_0_248 VGND VPWR sky130_fd_sc_hd__tapvpwrvgnd_1
X_6983_ clkload6/A _6983_/D _6263_/Y VGND VGND VPWR VPWR _6983_/Q sky130_fd_sc_hd__dfrtp_2
XFILLER_53_436 VGND VGND VPWR VPWR sky130_fd_sc_hd__decap_3
XFILLER_19_691 VGND VGND VPWR VPWR sky130_fd_sc_hd__decap_3
XTAP_TAPCELL_ROW_0_259 VGND VPWR sky130_fd_sc_hd__tapvpwrvgnd_1
XFILLER_80_277 VGND VGND VPWR VPWR sky130_fd_sc_hd__decap_3
XFILLER_34_672 VGND VGND VPWR VPWR sky130_fd_sc_hd__decap_3
XPHY_EDGE_ROW_38_Left_162 VGND VGND VPWR VPWR sky130_fd_sc_hd__decap_3
XFILLER_21_333 VGND VGND VPWR VPWR sky130_fd_sc_hd__decap_3
X_4816_ _4970_/A1 _4652_/A _4813_/A _5033_/B2 VGND VGND VPWR VPWR _4816_/X sky130_fd_sc_hd__a22o_2
XTAP_TAPCELL_ROW_60_1050 VGND VPWR sky130_fd_sc_hd__tapvpwrvgnd_1
X_4747_ _4739_/Y _4740_/X _4743_/X _4746_/X VGND VGND VPWR VPWR _5664_/B sky130_fd_sc_hd__o211a_2
X_4678_ _6988_/Q _4674_/X _5045_/B _5036_/A VGND VGND VPWR VPWR _5014_/B sky130_fd_sc_hd__a31o_2
XFILLER_119_287 VGND VGND VPWR VPWR sky130_fd_sc_hd__decap_3
XFILLER_110_9 VGND VGND VPWR VPWR sky130_fd_sc_hd__decap_3
X_6417_ _6650_/A VGND VGND VPWR VPWR _6417_/Y sky130_fd_sc_hd__inv_2
XFILLER_107_449 VGND VGND VPWR VPWR sky130_fd_sc_hd__decap_3
X_3629_ _3682_/A VGND VGND VPWR VPWR _3629_/Y sky130_fd_sc_hd__inv_2
X_7397_ _7404_/CLK _7397_/D _6677_/Y VGND VGND VPWR VPWR _7397_/Q sky130_fd_sc_hd__dfrtp_2
XTAP_TAPCELL_ROW_112_1725 VGND VPWR sky130_fd_sc_hd__tapvpwrvgnd_1
XFILLER_103_600 VGND VGND VPWR VPWR sky130_fd_sc_hd__decap_3
X_6348_ _6672_/A VGND VGND VPWR VPWR _6348_/Y sky130_fd_sc_hd__inv_2
XPHY_EDGE_ROW_47_Left_171 VGND VGND VPWR VPWR sky130_fd_sc_hd__decap_3
XFILLER_103_644 VGND VGND VPWR VPWR sky130_fd_sc_hd__decap_3
XFILLER_88_344 VGND VGND VPWR VPWR sky130_fd_sc_hd__decap_3
XFILLER_49_709 VGND VGND VPWR VPWR sky130_fd_sc_hd__decap_3
XFILLER_0_248 VGND VGND VPWR VPWR sky130_fd_sc_hd__decap_3
X_6279_ _6462_/A VGND VGND VPWR VPWR _6279_/Y sky130_fd_sc_hd__inv_2
XFILLER_102_132 VGND VGND VPWR VPWR sky130_fd_sc_hd__decap_3
XFILLER_0_259 VGND VGND VPWR VPWR sky130_fd_sc_hd__fill_2
XFILLER_88_377 VGND VGND VPWR VPWR sky130_fd_sc_hd__decap_3
XFILLER_103_688 VGND VGND VPWR VPWR sky130_fd_sc_hd__decap_3
XTAP_TAPCELL_ROW_71_1190 VGND VPWR sky130_fd_sc_hd__tapvpwrvgnd_1
XFILLER_29_444 VGND VGND VPWR VPWR sky130_fd_sc_hd__decap_3
XFILLER_17_606 VGND VGND VPWR VPWR sky130_fd_sc_hd__decap_3
XFILLER_72_701 VGND VGND VPWR VPWR sky130_fd_sc_hd__decap_3
XFILLER_56_68 VGND VGND VPWR VPWR sky130_fd_sc_hd__fill_2
XFILLER_17_617 VGND VGND VPWR VPWR sky130_fd_sc_hd__decap_3
XTAP_TAPCELL_ROW_27_612 VGND VPWR sky130_fd_sc_hd__tapvpwrvgnd_1
XFILLER_72_734 VGND VGND VPWR VPWR sky130_fd_sc_hd__fill_1
XTAP_TAPCELL_ROW_27_623 VGND VPWR sky130_fd_sc_hd__tapvpwrvgnd_1
XFILLER_44_436 VGND VGND VPWR VPWR sky130_fd_sc_hd__decap_3
XFILLER_112_41 VGND VGND VPWR VPWR sky130_fd_sc_hd__decap_3
XFILLER_16_149 VGND VGND VPWR VPWR sky130_fd_sc_hd__fill_1
XFILLER_71_255 VGND VGND VPWR VPWR sky130_fd_sc_hd__fill_1
XFILLER_44_469 VGND VGND VPWR VPWR sky130_fd_sc_hd__decap_3
XTAP_TAPCELL_ROW_55_976 VGND VPWR sky130_fd_sc_hd__tapvpwrvgnd_1
XFILLER_72_23 VGND VGND VPWR VPWR sky130_fd_sc_hd__decap_3
XFILLER_25_650 VGND VGND VPWR VPWR sky130_fd_sc_hd__decap_3
XFILLER_112_74 VGND VGND VPWR VPWR sky130_fd_sc_hd__fill_1
XPHY_EDGE_ROW_56_Left_180 VGND VGND VPWR VPWR sky130_fd_sc_hd__decap_3
XTAP_TAPCELL_ROW_55_987 VGND VPWR sky130_fd_sc_hd__tapvpwrvgnd_1
XFILLER_112_85 VGND VGND VPWR VPWR sky130_fd_sc_hd__decap_3
XTAP_TAPCELL_ROW_123_1865 VGND VPWR sky130_fd_sc_hd__tapvpwrvgnd_1
XTAP_TAPCELL_ROW_123_1876 VGND VPWR sky130_fd_sc_hd__tapvpwrvgnd_1
XFILLER_71_299 VGND VGND VPWR VPWR sky130_fd_sc_hd__decap_3
XFILLER_25_694 VGND VGND VPWR VPWR sky130_fd_sc_hd__decap_3
XFILLER_52_480 VGND VGND VPWR VPWR sky130_fd_sc_hd__decap_3
XFILLER_24_171 VGND VGND VPWR VPWR sky130_fd_sc_hd__decap_3
XFILLER_40_631 VGND VGND VPWR VPWR sky130_fd_sc_hd__decap_3
XFILLER_12_322 VGND VGND VPWR VPWR sky130_fd_sc_hd__decap_3
XFILLER_12_355 VGND VGND VPWR VPWR sky130_fd_sc_hd__decap_3
XFILLER_40_675 VGND VGND VPWR VPWR sky130_fd_sc_hd__decap_3
XFILLER_21_60 VGND VGND VPWR VPWR sky130_fd_sc_hd__decap_3
XFILLER_99_609 VGND VGND VPWR VPWR sky130_fd_sc_hd__decap_3
XFILLER_4_554 VGND VGND VPWR VPWR sky130_fd_sc_hd__decap_3
XFILLER_113_408 VGND VGND VPWR VPWR sky130_fd_sc_hd__fill_2
XFILLER_97_20 VGND VGND VPWR VPWR sky130_fd_sc_hd__decap_3
XFILLER_4_587 VGND VGND VPWR VPWR sky130_fd_sc_hd__fill_1
XFILLER_97_53 VGND VGND VPWR VPWR sky130_fd_sc_hd__decap_3
XFILLER_4_598 VGND VGND VPWR VPWR sky130_fd_sc_hd__decap_3
XFILLER_121_452 VGND VGND VPWR VPWR sky130_fd_sc_hd__decap_3
XFILLER_94_303 VGND VGND VPWR VPWR sky130_fd_sc_hd__decap_3
XFILLER_79_399 VGND VGND VPWR VPWR sky130_fd_sc_hd__decap_3
XFILLER_121_485 VGND VGND VPWR VPWR sky130_fd_sc_hd__decap_3
XFILLER_48_731 VGND VGND VPWR VPWR sky130_fd_sc_hd__decap_3
XFILLER_63_712 VGND VGND VPWR VPWR sky130_fd_sc_hd__decap_3
XFILLER_62_200 VGND VGND VPWR VPWR sky130_fd_sc_hd__decap_3
XFILLER_75_594 VGND VGND VPWR VPWR sky130_fd_sc_hd__decap_3
XFILLER_35_447 VGND VGND VPWR VPWR sky130_fd_sc_hd__fill_1
XFILLER_62_244 VGND VGND VPWR VPWR sky130_fd_sc_hd__fill_1
XFILLER_90_575 VGND VGND VPWR VPWR sky130_fd_sc_hd__decap_3
XFILLER_16_672 VGND VGND VPWR VPWR sky130_fd_sc_hd__decap_3
XFILLER_22_119 VGND VGND VPWR VPWR sky130_fd_sc_hd__decap_3
XFILLER_50_439 VGND VGND VPWR VPWR sky130_fd_sc_hd__decap_3
XFILLER_15_160 VGND VGND VPWR VPWR sky130_fd_sc_hd__decap_3
XFILLER_31_620 VGND VGND VPWR VPWR sky130_fd_sc_hd__decap_3
X_5650_ _5650_/A VGND VGND VPWR VPWR _5650_/Y sky130_fd_sc_hd__inv_2
Xclkbuf_0_clk clk VGND VGND VPWR VPWR clkbuf_0_clk/X sky130_fd_sc_hd__clkbuf_16
XFILLER_31_653 VGND VGND VPWR VPWR sky130_fd_sc_hd__decap_3
XFILLER_87_3 VGND VGND VPWR VPWR sky130_fd_sc_hd__decap_3
X_4601_ _4601_/A0 _5157_/A0 _4601_/S VGND VGND VPWR VPWR _7280_/D sky130_fd_sc_hd__mux2_2
XFILLER_31_697 VGND VGND VPWR VPWR sky130_fd_sc_hd__decap_3
X_5581_ hold987/X _5069_/X _5581_/S VGND VGND VPWR VPWR _7038_/D sky130_fd_sc_hd__mux2_2
XFILLER_117_703 VGND VGND VPWR VPWR sky130_fd_sc_hd__decap_3
X_7320_ _7345_/CLK _7320_/D _6600_/Y VGND VGND VPWR VPWR _7320_/Q sky130_fd_sc_hd__dfrtp_2
X_4532_ hold996/X _7281_/Q _4532_/S VGND VGND VPWR VPWR _7313_/D sky130_fd_sc_hd__mux2_2
X_7251_ _7352_/CLK _7251_/D _6531_/Y VGND VGND VPWR VPWR _7251_/Q sky130_fd_sc_hd__dfrtp_2
X_4463_ _4460_/Y _3541_/B _5057_/A _4462_/Y VGND VGND VPWR VPWR _4463_/X sky130_fd_sc_hd__a22o_2
XFILLER_116_246 VGND VGND VPWR VPWR sky130_fd_sc_hd__decap_3
X_3414_ _3421_/C VGND VGND VPWR VPWR _3449_/C sky130_fd_sc_hd__inv_4
XFILLER_89_119 VGND VGND VPWR VPWR sky130_fd_sc_hd__fill_1
XPHY_EDGE_ROW_15_Right_15 VGND VGND VPWR VPWR sky130_fd_sc_hd__decap_3
X_7182_ _7370_/CLK _7182_/D _6462_/Y VGND VGND VPWR VPWR _7182_/Q sky130_fd_sc_hd__dfrtp_2
X_4394_ _4394_/A _4394_/B _4393_/X VGND VGND VPWR VPWR _4444_/B sky130_fd_sc_hd__or3b_2
XFILLER_98_631 VGND VGND VPWR VPWR sky130_fd_sc_hd__decap_3
XFILLER_112_430 VGND VGND VPWR VPWR sky130_fd_sc_hd__decap_3
X_3345_ _5666_/A _4677_/B VGND VGND VPWR VPWR _3346_/A sky130_fd_sc_hd__nor2_4
XFILLER_98_675 VGND VGND VPWR VPWR sky130_fd_sc_hd__decap_3
XFILLER_58_506 VGND VGND VPWR VPWR sky130_fd_sc_hd__decap_3
XTAP_TAPCELL_ROW_5_329 VGND VPWR sky130_fd_sc_hd__tapvpwrvgnd_1
XFILLER_97_163 VGND VGND VPWR VPWR sky130_fd_sc_hd__decap_3
XFILLER_85_314 VGND VGND VPWR VPWR sky130_fd_sc_hd__decap_3
Xhold1004 _7196_/Q VGND VGND VPWR VPWR _5268_/A0 sky130_fd_sc_hd__dlygate4sd3_1
XFILLER_100_625 VGND VGND VPWR VPWR sky130_fd_sc_hd__decap_3
Xhold1015 _7254_/Q VGND VGND VPWR VPWR _5122_/A0 sky130_fd_sc_hd__dlygate4sd3_1
Xhold1026 _7243_/Q VGND VGND VPWR VPWR _5169_/A sky130_fd_sc_hd__dlygate4sd3_1
X_5015_ _5015_/A _5015_/B _5015_/C VGND VGND VPWR VPWR _5015_/X sky130_fd_sc_hd__and3_2
Xhold1037 _7219_/Q VGND VGND VPWR VPWR _5219_/A sky130_fd_sc_hd__dlygate4sd3_1
Xhold1048 _7306_/Q VGND VGND VPWR VPWR _4548_/A sky130_fd_sc_hd__dlygate4sd3_1
XFILLER_100_669 VGND VGND VPWR VPWR sky130_fd_sc_hd__decap_3
Xhold1059 _7185_/Q VGND VGND VPWR VPWR _5288_/A0 sky130_fd_sc_hd__dlygate4sd3_1
XFILLER_66_550 VGND VGND VPWR VPWR sky130_fd_sc_hd__decap_3
XFILLER_38_241 VGND VGND VPWR VPWR sky130_fd_sc_hd__fill_2
XFILLER_54_701 VGND VGND VPWR VPWR sky130_fd_sc_hd__decap_3
XFILLER_26_403 VGND VGND VPWR VPWR sky130_fd_sc_hd__decap_3
XFILLER_38_274 VGND VGND VPWR VPWR sky130_fd_sc_hd__decap_3
XFILLER_54_734 VGND VGND VPWR VPWR sky130_fd_sc_hd__fill_1
XFILLER_53_211 VGND VGND VPWR VPWR sky130_fd_sc_hd__decap_3
XPHY_EDGE_ROW_24_Right_24 VGND VGND VPWR VPWR sky130_fd_sc_hd__decap_3
XFILLER_81_564 VGND VGND VPWR VPWR sky130_fd_sc_hd__decap_3
X_6966_ clkload9/A _6966_/D VGND VGND VPWR VPWR _6966_/Q sky130_fd_sc_hd__dfxtp_2
XFILLER_81_597 VGND VGND VPWR VPWR sky130_fd_sc_hd__decap_3
XFILLER_53_299 VGND VGND VPWR VPWR sky130_fd_sc_hd__decap_3
XTAP_TAPCELL_ROW_52_946 VGND VPWR sky130_fd_sc_hd__tapvpwrvgnd_1
XFILLER_34_480 VGND VGND VPWR VPWR sky130_fd_sc_hd__decap_3
X_6897_ _6926_/CLK _6897_/D VGND VGND VPWR VPWR _6897_/Q sky130_fd_sc_hd__dfxtp_2
XFILLER_22_631 VGND VGND VPWR VPWR sky130_fd_sc_hd__decap_3
XFILLER_42_26 VGND VGND VPWR VPWR sky130_fd_sc_hd__fill_2
XFILLER_22_675 VGND VGND VPWR VPWR sky130_fd_sc_hd__decap_3
XTAP_TAPCELL_ROW_32_681 VGND VPWR sky130_fd_sc_hd__tapvpwrvgnd_1
XFILLER_21_196 VGND VGND VPWR VPWR sky130_fd_sc_hd__decap_3
XFILLER_108_725 VGND VGND VPWR VPWR sky130_fd_sc_hd__decap_3
XPHY_EDGE_ROW_33_Right_33 VGND VGND VPWR VPWR sky130_fd_sc_hd__decap_3
XFILLER_1_502 VGND VGND VPWR VPWR sky130_fd_sc_hd__fill_2
Xhold860 _7058_/Q VGND VGND VPWR VPWR _7058_/D sky130_fd_sc_hd__dlygate4sd3_1
XFILLER_89_620 VGND VGND VPWR VPWR sky130_fd_sc_hd__decap_3
Xhold871 _7093_/Q VGND VGND VPWR VPWR _7093_/D sky130_fd_sc_hd__dlygate4sd3_1
Xhold882 _7067_/Q VGND VGND VPWR VPWR _7067_/D sky130_fd_sc_hd__dlygate4sd3_1
XFILLER_1_535 VGND VGND VPWR VPWR sky130_fd_sc_hd__decap_3
Xhold893 _7108_/Q VGND VGND VPWR VPWR _7108_/D sky130_fd_sc_hd__dlygate4sd3_1
XFILLER_107_52 VGND VGND VPWR VPWR sky130_fd_sc_hd__decap_3
XFILLER_89_653 VGND VGND VPWR VPWR sky130_fd_sc_hd__decap_3
XFILLER_88_130 VGND VGND VPWR VPWR sky130_fd_sc_hd__decap_3
XFILLER_88_141 VGND VGND VPWR VPWR sky130_fd_sc_hd__decap_3
XFILLER_67_12 VGND VGND VPWR VPWR sky130_fd_sc_hd__decap_3
XFILLER_107_74 VGND VGND VPWR VPWR sky130_fd_sc_hd__decap_3
XFILLER_103_452 VGND VGND VPWR VPWR sky130_fd_sc_hd__decap_3
XFILLER_1_579 VGND VGND VPWR VPWR sky130_fd_sc_hd__decap_3
XFILLER_67_45 VGND VGND VPWR VPWR sky130_fd_sc_hd__decap_3
XFILLER_89_697 VGND VGND VPWR VPWR sky130_fd_sc_hd__decap_3
XFILLER_29_241 VGND VGND VPWR VPWR sky130_fd_sc_hd__decap_3
XFILLER_57_561 VGND VGND VPWR VPWR sky130_fd_sc_hd__fill_2
XFILLER_45_712 VGND VGND VPWR VPWR sky130_fd_sc_hd__decap_3
XFILLER_29_263 VGND VGND VPWR VPWR sky130_fd_sc_hd__fill_2
XFILLER_44_200 VGND VGND VPWR VPWR sky130_fd_sc_hd__fill_2
XFILLER_17_414 VGND VGND VPWR VPWR sky130_fd_sc_hd__decap_3
XPHY_EDGE_ROW_42_Right_42 VGND VGND VPWR VPWR sky130_fd_sc_hd__decap_3
XFILLER_83_33 VGND VGND VPWR VPWR sky130_fd_sc_hd__decap_3
XFILLER_84_391 VGND VGND VPWR VPWR sky130_fd_sc_hd__decap_3
XFILLER_72_542 VGND VGND VPWR VPWR sky130_fd_sc_hd__decap_3
XFILLER_60_704 VGND VGND VPWR VPWR sky130_fd_sc_hd__decap_3
XFILLER_83_77 VGND VGND VPWR VPWR sky130_fd_sc_hd__decap_3
XFILLER_32_428 VGND VGND VPWR VPWR sky130_fd_sc_hd__decap_3
XFILLER_13_620 VGND VGND VPWR VPWR sky130_fd_sc_hd__decap_3
XFILLER_13_653 VGND VGND VPWR VPWR sky130_fd_sc_hd__decap_3
XFILLER_12_141 VGND VGND VPWR VPWR sky130_fd_sc_hd__decap_3
XFILLER_9_635 VGND VGND VPWR VPWR sky130_fd_sc_hd__decap_3
XFILLER_13_697 VGND VGND VPWR VPWR sky130_fd_sc_hd__decap_3
XFILLER_12_174 VGND VGND VPWR VPWR sky130_fd_sc_hd__decap_3
XFILLER_40_483 VGND VGND VPWR VPWR sky130_fd_sc_hd__decap_3
XFILLER_9_668 VGND VGND VPWR VPWR sky130_fd_sc_hd__decap_3
XFILLER_73_9 VGND VGND VPWR VPWR sky130_fd_sc_hd__decap_3
XFILLER_9_679 VGND VGND VPWR VPWR sky130_fd_sc_hd__decap_3
XFILLER_32_81 VGND VGND VPWR VPWR sky130_fd_sc_hd__decap_3
XPHY_EDGE_ROW_51_Right_51 VGND VGND VPWR VPWR sky130_fd_sc_hd__decap_3
XTAP_TAPCELL_ROW_10_397 VGND VPWR sky130_fd_sc_hd__tapvpwrvgnd_1
XFILLER_99_406 VGND VGND VPWR VPWR sky130_fd_sc_hd__decap_3
XFILLER_114_728 VGND VGND VPWR VPWR sky130_fd_sc_hd__decap_3
XFILLER_4_362 VGND VGND VPWR VPWR sky130_fd_sc_hd__fill_2
XFILLER_95_612 VGND VGND VPWR VPWR sky130_fd_sc_hd__decap_3
XFILLER_95_623 VGND VGND VPWR VPWR sky130_fd_sc_hd__decap_3
XFILLER_94_100 VGND VGND VPWR VPWR sky130_fd_sc_hd__fill_1
XFILLER_67_325 VGND VGND VPWR VPWR sky130_fd_sc_hd__decap_3
XFILLER_95_656 VGND VGND VPWR VPWR sky130_fd_sc_hd__decap_3
XFILLER_94_144 VGND VGND VPWR VPWR sky130_fd_sc_hd__decap_3
XPHY_EDGE_ROW_60_Right_60 VGND VGND VPWR VPWR sky130_fd_sc_hd__decap_3
XFILLER_48_561 VGND VGND VPWR VPWR sky130_fd_sc_hd__decap_3
XFILLER_36_701 VGND VGND VPWR VPWR sky130_fd_sc_hd__decap_3
XFILLER_36_734 VGND VGND VPWR VPWR sky130_fd_sc_hd__fill_1
XFILLER_63_520 VGND VGND VPWR VPWR sky130_fd_sc_hd__fill_2
X_6820_ _7380_/CLK _6820_/D VGND VGND VPWR VPWR _6820_/Q sky130_fd_sc_hd__dfxtp_2
XFILLER_63_564 VGND VGND VPWR VPWR sky130_fd_sc_hd__decap_3
XFILLER_35_255 VGND VGND VPWR VPWR sky130_fd_sc_hd__decap_3
XFILLER_90_361 VGND VGND VPWR VPWR sky130_fd_sc_hd__decap_3
XFILLER_51_715 VGND VGND VPWR VPWR sky130_fd_sc_hd__decap_3
XFILLER_23_406 VGND VGND VPWR VPWR sky130_fd_sc_hd__decap_3
XFILLER_50_203 VGND VGND VPWR VPWR sky130_fd_sc_hd__decap_3
XFILLER_35_277 VGND VGND VPWR VPWR sky130_fd_sc_hd__decap_3
XFILLER_90_383 VGND VGND VPWR VPWR sky130_fd_sc_hd__decap_3
X_6751_ _6978_/CLK _6751_/D VGND VGND VPWR VPWR _6751_/Q sky130_fd_sc_hd__dfxtp_2
XFILLER_50_225 VGND VGND VPWR VPWR sky130_fd_sc_hd__decap_3
XFILLER_35_299 VGND VGND VPWR VPWR sky130_fd_sc_hd__fill_2
XTAP_TAPCELL_ROW_18_497 VGND VPWR sky130_fd_sc_hd__tapvpwrvgnd_1
X_6682_ _6684_/A VGND VGND VPWR VPWR _6682_/Y sky130_fd_sc_hd__inv_2
X_3894_ _3728_/Y _3891_/X _3893_/X _3733_/X VGND VGND VPWR VPWR _3894_/X sky130_fd_sc_hd__a22o_2
XFILLER_31_461 VGND VGND VPWR VPWR sky130_fd_sc_hd__fill_1
X_5633_ _5633_/A _5633_/B VGND VGND VPWR VPWR _7012_/D sky130_fd_sc_hd__nor2_2
XTAP_TAPCELL_ROW_98_1539 VGND VPWR sky130_fd_sc_hd__tapvpwrvgnd_1
XFILLER_117_500 VGND VGND VPWR VPWR sky130_fd_sc_hd__decap_3
X_5564_ hold954/X _4909_/A _4751_/B VGND VGND VPWR VPWR _7052_/D sky130_fd_sc_hd__a21bo_2
XFILLER_117_511 VGND VGND VPWR VPWR sky130_fd_sc_hd__decap_3
XFILLER_8_690 VGND VGND VPWR VPWR sky130_fd_sc_hd__decap_3
X_4515_ _4515_/A0 _7290_/Q _4520_/S VGND VGND VPWR VPWR _7322_/D sky130_fd_sc_hd__mux2_2
X_7303_ _7399_/CLK _7303_/D _6583_/Y VGND VGND VPWR VPWR _7303_/Q sky130_fd_sc_hd__dfrtp_2
XFILLER_117_544 VGND VGND VPWR VPWR sky130_fd_sc_hd__decap_3
XFILLER_105_706 VGND VGND VPWR VPWR sky130_fd_sc_hd__decap_3
XPHY_EDGE_ROW_103_Right_103 VGND VGND VPWR VPWR sky130_fd_sc_hd__decap_3
XFILLER_117_588 VGND VGND VPWR VPWR sky130_fd_sc_hd__decap_3
X_4446_ _4446_/A _4814_/B VGND VGND VPWR VPWR _4447_/B sky130_fd_sc_hd__nor2_2
X_7234_ _7359_/CLK _7234_/D _6514_/Y VGND VGND VPWR VPWR _7234_/Q sky130_fd_sc_hd__dfrtp_2
XFILLER_104_249 VGND VGND VPWR VPWR sky130_fd_sc_hd__decap_3
X_7165_ _7356_/CLK _7165_/D _6445_/Y VGND VGND VPWR VPWR _7165_/Q sky130_fd_sc_hd__dfrtp_2
X_4377_ _4277_/B _4375_/X _4376_/X VGND VGND VPWR VPWR _4377_/Y sky130_fd_sc_hd__o21ai_2
XFILLER_86_601 VGND VGND VPWR VPWR sky130_fd_sc_hd__decap_3
XFILLER_98_472 VGND VGND VPWR VPWR sky130_fd_sc_hd__decap_3
X_3328_ _3328_/A _3328_/B VGND VGND VPWR VPWR _3340_/C sky130_fd_sc_hd__nor2_2
XFILLER_85_100 VGND VGND VPWR VPWR sky130_fd_sc_hd__decap_3
X_7096_ _7354_/CLK _7096_/D _6376_/Y VGND VGND VPWR VPWR _7096_/Q sky130_fd_sc_hd__dfrtp_2
XFILLER_86_634 VGND VGND VPWR VPWR sky130_fd_sc_hd__decap_3
XFILLER_112_271 VGND VGND VPWR VPWR sky130_fd_sc_hd__decap_3
XFILLER_86_645 VGND VGND VPWR VPWR sky130_fd_sc_hd__decap_3
XFILLER_85_122 VGND VGND VPWR VPWR sky130_fd_sc_hd__fill_2
XFILLER_112_293 VGND VGND VPWR VPWR sky130_fd_sc_hd__decap_3
XFILLER_100_433 VGND VGND VPWR VPWR sky130_fd_sc_hd__fill_2
XFILLER_58_358 VGND VGND VPWR VPWR sky130_fd_sc_hd__decap_3
XFILLER_86_678 VGND VGND VPWR VPWR sky130_fd_sc_hd__decap_3
XFILLER_85_155 VGND VGND VPWR VPWR sky130_fd_sc_hd__decap_3
XFILLER_37_37 VGND VGND VPWR VPWR sky130_fd_sc_hd__fill_2
XFILLER_39_561 VGND VGND VPWR VPWR sky130_fd_sc_hd__decap_3
XFILLER_27_712 VGND VGND VPWR VPWR sky130_fd_sc_hd__decap_3
XFILLER_100_477 VGND VGND VPWR VPWR sky130_fd_sc_hd__decap_3
XFILLER_26_200 VGND VGND VPWR VPWR sky130_fd_sc_hd__fill_1
XFILLER_26_211 VGND VGND VPWR VPWR sky130_fd_sc_hd__decap_3
XTAP_TAPCELL_ROW_107_1657 VGND VPWR sky130_fd_sc_hd__tapvpwrvgnd_1
XTAP_TAPCELL_ROW_37_751 VGND VPWR sky130_fd_sc_hd__tapvpwrvgnd_1
XFILLER_42_704 VGND VGND VPWR VPWR sky130_fd_sc_hd__decap_3
XFILLER_54_575 VGND VGND VPWR VPWR sky130_fd_sc_hd__decap_3
XFILLER_41_225 VGND VGND VPWR VPWR sky130_fd_sc_hd__decap_3
XTAP_TAPCELL_ROW_120_1824 VGND VPWR sky130_fd_sc_hd__tapvpwrvgnd_1
X_6949_ _6967_/CLK _6949_/D VGND VGND VPWR VPWR _6949_/Q sky130_fd_sc_hd__dfxtp_2
XFILLER_41_269 VGND VGND VPWR VPWR sky130_fd_sc_hd__decap_3
XFILLER_10_601 VGND VGND VPWR VPWR sky130_fd_sc_hd__decap_3
XFILLER_22_461 VGND VGND VPWR VPWR sky130_fd_sc_hd__decap_3
XFILLER_22_483 VGND VGND VPWR VPWR sky130_fd_sc_hd__decap_3
XFILLER_10_634 VGND VGND VPWR VPWR sky130_fd_sc_hd__decap_3
XFILLER_10_645 VGND VGND VPWR VPWR sky130_fd_sc_hd__decap_3
XFILLER_6_616 VGND VGND VPWR VPWR sky130_fd_sc_hd__decap_3
XFILLER_10_678 VGND VGND VPWR VPWR sky130_fd_sc_hd__decap_3
XFILLER_108_533 VGND VGND VPWR VPWR sky130_fd_sc_hd__decap_3
XFILLER_108_566 VGND VGND VPWR VPWR sky130_fd_sc_hd__decap_3
XTAP_TAPCELL_ROW_118_1797 VGND VPWR sky130_fd_sc_hd__tapvpwrvgnd_1
XFILLER_123_503 VGND VGND VPWR VPWR sky130_fd_sc_hd__fill_1
XFILLER_118_62 VGND VGND VPWR VPWR sky130_fd_sc_hd__decap_3
XFILLER_123_536 VGND VGND VPWR VPWR sky130_fd_sc_hd__decap_3
XFILLER_111_709 VGND VGND VPWR VPWR sky130_fd_sc_hd__decap_3
Xhold690 _6951_/Q VGND VGND VPWR VPWR _6951_/D sky130_fd_sc_hd__dlygate4sd3_1
XFILLER_78_66 VGND VGND VPWR VPWR sky130_fd_sc_hd__decap_3
XFILLER_89_461 VGND VGND VPWR VPWR sky130_fd_sc_hd__decap_3
XFILLER_78_88 VGND VGND VPWR VPWR sky130_fd_sc_hd__decap_3
XFILLER_77_612 VGND VGND VPWR VPWR sky130_fd_sc_hd__decap_3
XFILLER_77_623 VGND VGND VPWR VPWR sky130_fd_sc_hd__decap_3
XFILLER_49_314 VGND VGND VPWR VPWR sky130_fd_sc_hd__decap_3
XFILLER_77_656 VGND VGND VPWR VPWR sky130_fd_sc_hd__decap_3
XFILLER_49_347 VGND VGND VPWR VPWR sky130_fd_sc_hd__decap_3
XFILLER_94_32 VGND VGND VPWR VPWR sky130_fd_sc_hd__fill_1
XFILLER_92_604 VGND VGND VPWR VPWR sky130_fd_sc_hd__decap_3
XFILLER_76_155 VGND VGND VPWR VPWR sky130_fd_sc_hd__fill_1
XFILLER_64_306 VGND VGND VPWR VPWR sky130_fd_sc_hd__fill_2
XFILLER_18_701 VGND VGND VPWR VPWR sky130_fd_sc_hd__decap_3
XFILLER_91_103 VGND VGND VPWR VPWR sky130_fd_sc_hd__decap_3
XFILLER_92_637 VGND VGND VPWR VPWR sky130_fd_sc_hd__decap_3
XFILLER_92_648 VGND VGND VPWR VPWR sky130_fd_sc_hd__decap_3
XFILLER_18_734 VGND VGND VPWR VPWR sky130_fd_sc_hd__fill_1
XFILLER_45_542 VGND VGND VPWR VPWR sky130_fd_sc_hd__fill_2
XFILLER_33_715 VGND VGND VPWR VPWR sky130_fd_sc_hd__decap_3
XFILLER_60_501 VGND VGND VPWR VPWR sky130_fd_sc_hd__decap_3
XFILLER_32_203 VGND VGND VPWR VPWR sky130_fd_sc_hd__decap_3
XTAP_TAPCELL_ROW_82_1329 VGND VPWR sky130_fd_sc_hd__tapvpwrvgnd_1
XFILLER_72_383 VGND VGND VPWR VPWR sky130_fd_sc_hd__fill_1
XFILLER_32_225 VGND VGND VPWR VPWR sky130_fd_sc_hd__decap_3
XTAP_TAPCELL_ROW_15_456 VGND VPWR sky130_fd_sc_hd__tapvpwrvgnd_1
XTAP_TAPCELL_ROW_15_467 VGND VPWR sky130_fd_sc_hd__tapvpwrvgnd_1
XFILLER_9_443 VGND VGND VPWR VPWR sky130_fd_sc_hd__decap_3
XFILLER_40_291 VGND VGND VPWR VPWR sky130_fd_sc_hd__decap_3
XFILLER_71_6 VGND VGND VPWR VPWR sky130_fd_sc_hd__decap_3
X_4300_ _7288_/Q _4532_/S VGND VGND VPWR VPWR _4300_/X sky130_fd_sc_hd__and2_2
XFILLER_114_514 VGND VGND VPWR VPWR sky130_fd_sc_hd__decap_3
XFILLER_5_671 VGND VGND VPWR VPWR sky130_fd_sc_hd__fill_1
X_5280_ hold986/X _5121_/X _5292_/S VGND VGND VPWR VPWR _7190_/D sky130_fd_sc_hd__mux2_2
XFILLER_99_225 VGND VGND VPWR VPWR sky130_fd_sc_hd__decap_3
XFILLER_5_682 VGND VGND VPWR VPWR sky130_fd_sc_hd__decap_3
XFILLER_114_536 VGND VGND VPWR VPWR sky130_fd_sc_hd__decap_3
XFILLER_99_247 VGND VGND VPWR VPWR sky130_fd_sc_hd__decap_3
X_4231_ _7040_/Q _4244_/B _4261_/A2 _7387_/Q _4230_/X VGND VGND VPWR VPWR _4231_/X
+ sky130_fd_sc_hd__a221o_2
XFILLER_114_569 VGND VGND VPWR VPWR sky130_fd_sc_hd__decap_3
XFILLER_4_63 VGND VGND VPWR VPWR sky130_fd_sc_hd__decap_3
XFILLER_68_601 VGND VGND VPWR VPWR sky130_fd_sc_hd__decap_3
XFILLER_101_208 VGND VGND VPWR VPWR sky130_fd_sc_hd__decap_3
X_4162_ _7137_/Q _4348_/B1 _4161_/X VGND VGND VPWR VPWR _4203_/A sky130_fd_sc_hd__a21o_2
XFILLER_68_634 VGND VGND VPWR VPWR sky130_fd_sc_hd__decap_3
XFILLER_4_96 VGND VGND VPWR VPWR sky130_fd_sc_hd__fill_2
XFILLER_95_420 VGND VGND VPWR VPWR sky130_fd_sc_hd__decap_3
XFILLER_68_645 VGND VGND VPWR VPWR sky130_fd_sc_hd__decap_3
XFILLER_110_731 VGND VGND VPWR VPWR sky130_fd_sc_hd__decap_3
XFILLER_95_464 VGND VGND VPWR VPWR sky130_fd_sc_hd__decap_3
XFILLER_68_678 VGND VGND VPWR VPWR sky130_fd_sc_hd__decap_3
X_4093_ _4394_/A _4394_/B _4092_/X VGND VGND VPWR VPWR _4210_/B sky130_fd_sc_hd__or3b_2
XFILLER_83_615 VGND VGND VPWR VPWR sky130_fd_sc_hd__fill_1
XFILLER_67_166 VGND VGND VPWR VPWR sky130_fd_sc_hd__fill_2
XFILLER_83_626 VGND VGND VPWR VPWR sky130_fd_sc_hd__decap_3
XFILLER_82_103 VGND VGND VPWR VPWR sky130_fd_sc_hd__decap_3
XFILLER_83_659 VGND VGND VPWR VPWR sky130_fd_sc_hd__decap_3
XFILLER_82_125 VGND VGND VPWR VPWR sky130_fd_sc_hd__decap_3
XFILLER_82_147 VGND VGND VPWR VPWR sky130_fd_sc_hd__decap_3
XFILLER_82_169 VGND VGND VPWR VPWR sky130_fd_sc_hd__fill_2
XFILLER_70_309 VGND VGND VPWR VPWR sky130_fd_sc_hd__decap_3
XFILLER_24_704 VGND VGND VPWR VPWR sky130_fd_sc_hd__decap_3
XFILLER_63_361 VGND VGND VPWR VPWR sky130_fd_sc_hd__decap_3
XTAP_TAPCELL_ROW_34_710 VGND VPWR sky130_fd_sc_hd__tapvpwrvgnd_1
X_6803_ _7405_/CLK _6803_/D VGND VGND VPWR VPWR _6803_/Q sky130_fd_sc_hd__dfxtp_2
Xplace350 _4337_/B VGND VGND VPWR VPWR _4270_/B sky130_fd_sc_hd__buf_2
Xplace361 _5140_/S VGND VGND VPWR VPWR _5080_/S sky130_fd_sc_hd__buf_2
Xplace372 _3509_/B VGND VGND VPWR VPWR _4791_/C1 sky130_fd_sc_hd__buf_2
XFILLER_90_191 VGND VGND VPWR VPWR sky130_fd_sc_hd__decap_3
X_4995_ _4811_/C _4987_/Y _4993_/X _4994_/X VGND VGND VPWR VPWR _5657_/D sky130_fd_sc_hd__a211o_2
Xplace383 _4348_/B1 VGND VGND VPWR VPWR _4428_/B1 sky130_fd_sc_hd__buf_2
XFILLER_51_567 VGND VGND VPWR VPWR sky130_fd_sc_hd__fill_2
Xplace394 _3326_/A VGND VGND VPWR VPWR _5648_/A sky130_fd_sc_hd__buf_2
X_6734_ _6960_/CLK _6734_/D VGND VGND VPWR VPWR _6734_/Q sky130_fd_sc_hd__dfxtp_2
XTAP_TAPCELL_ROW_102_1587 VGND VPWR sky130_fd_sc_hd__tapvpwrvgnd_1
XTAP_TAPCELL_ROW_102_1598 VGND VPWR sky130_fd_sc_hd__tapvpwrvgnd_1
X_3877_ _6906_/Q _3888_/A2 _3890_/B1 _6850_/Q _3876_/X VGND VGND VPWR VPWR _3877_/X
+ sky130_fd_sc_hd__a221o_2
X_6665_ _6672_/A VGND VGND VPWR VPWR _6665_/Y sky130_fd_sc_hd__inv_2
X_6596_ _6596_/A VGND VGND VPWR VPWR _6596_/Y sky130_fd_sc_hd__inv_2
XTAP_TAPCELL_ROW_57_1011 VGND VPWR sky130_fd_sc_hd__tapvpwrvgnd_1
XFILLER_117_363 VGND VGND VPWR VPWR sky130_fd_sc_hd__decap_3
XFILLER_117_396 VGND VGND VPWR VPWR sky130_fd_sc_hd__fill_1
XFILLER_105_558 VGND VGND VPWR VPWR sky130_fd_sc_hd__fill_2
X_4429_ _7303_/Q _4429_/A2 _4437_/B1 _7367_/Q _4429_/C1 VGND VGND VPWR VPWR _4429_/X
+ sky130_fd_sc_hd__a221o_2
X_7217_ _7313_/CLK _7217_/D _6497_/Y VGND VGND VPWR VPWR _7217_/Q sky130_fd_sc_hd__dfrtp_2
XFILLER_59_612 VGND VGND VPWR VPWR sky130_fd_sc_hd__decap_3
XFILLER_59_623 VGND VGND VPWR VPWR sky130_fd_sc_hd__decap_3
XFILLER_120_528 VGND VGND VPWR VPWR sky130_fd_sc_hd__decap_3
XFILLER_120_539 VGND VGND VPWR VPWR sky130_fd_sc_hd__decap_3
X_7148_ _7372_/CLK _7148_/D _6428_/Y VGND VGND VPWR VPWR _7148_/Q sky130_fd_sc_hd__dfrtp_2
XFILLER_113_591 VGND VGND VPWR VPWR sky130_fd_sc_hd__decap_3
XFILLER_86_442 VGND VGND VPWR VPWR sky130_fd_sc_hd__decap_3
XFILLER_59_656 VGND VGND VPWR VPWR sky130_fd_sc_hd__decap_3
XFILLER_100_230 VGND VGND VPWR VPWR sky130_fd_sc_hd__decap_3
XFILLER_58_144 VGND VGND VPWR VPWR sky130_fd_sc_hd__decap_3
X_7079_ _7399_/CLK _7079_/D _6359_/Y VGND VGND VPWR VPWR _7079_/Q sky130_fd_sc_hd__dfrtp_2
XFILLER_74_604 VGND VGND VPWR VPWR sky130_fd_sc_hd__decap_3
XFILLER_58_155 VGND VGND VPWR VPWR sky130_fd_sc_hd__decap_3
XFILLER_86_475 VGND VGND VPWR VPWR sky130_fd_sc_hd__fill_1
XFILLER_73_103 VGND VGND VPWR VPWR sky130_fd_sc_hd__decap_3
XFILLER_86_497 VGND VGND VPWR VPWR sky130_fd_sc_hd__fill_2
XFILLER_74_637 VGND VGND VPWR VPWR sky130_fd_sc_hd__decap_3
XFILLER_58_188 VGND VGND VPWR VPWR sky130_fd_sc_hd__decap_3
XFILLER_100_274 VGND VGND VPWR VPWR sky130_fd_sc_hd__decap_3
XFILLER_74_648 VGND VGND VPWR VPWR sky130_fd_sc_hd__decap_3
XFILLER_46_339 VGND VGND VPWR VPWR sky130_fd_sc_hd__fill_1
XFILLER_73_125 VGND VGND VPWR VPWR sky130_fd_sc_hd__decap_3
XFILLER_27_520 VGND VGND VPWR VPWR sky130_fd_sc_hd__fill_1
XFILLER_73_136 VGND VGND VPWR VPWR sky130_fd_sc_hd__decap_3
XFILLER_39_391 VGND VGND VPWR VPWR sky130_fd_sc_hd__fill_1
XTAP_TAPCELL_ROW_68_1151 VGND VPWR sky130_fd_sc_hd__tapvpwrvgnd_1
XFILLER_73_169 VGND VGND VPWR VPWR sky130_fd_sc_hd__decap_3
XFILLER_64_46 VGND VGND VPWR VPWR sky130_fd_sc_hd__decap_3
XFILLER_27_575 VGND VGND VPWR VPWR sky130_fd_sc_hd__decap_3
XFILLER_15_715 VGND VGND VPWR VPWR sky130_fd_sc_hd__decap_3
XFILLER_82_681 VGND VGND VPWR VPWR sky130_fd_sc_hd__decap_3
XFILLER_64_79 VGND VGND VPWR VPWR sky130_fd_sc_hd__decap_3
XFILLER_54_372 VGND VGND VPWR VPWR sky130_fd_sc_hd__decap_3
XFILLER_81_180 VGND VGND VPWR VPWR sky130_fd_sc_hd__decap_3
XFILLER_14_236 VGND VGND VPWR VPWR sky130_fd_sc_hd__fill_2
XFILLER_120_41 VGND VGND VPWR VPWR sky130_fd_sc_hd__decap_3
XFILLER_30_707 VGND VGND VPWR VPWR sky130_fd_sc_hd__decap_3
XFILLER_14_258 VGND VGND VPWR VPWR sky130_fd_sc_hd__fill_2
Xfanout40 _6570_/A VGND VGND VPWR VPWR _6640_/A sky130_fd_sc_hd__clkdlybuf4s25_1
XFILLER_42_589 VGND VGND VPWR VPWR sky130_fd_sc_hd__decap_3
XFILLER_120_74 VGND VGND VPWR VPWR sky130_fd_sc_hd__decap_3
Xfanout51 _6366_/A VGND VGND VPWR VPWR _6363_/A sky130_fd_sc_hd__buf_2
XFILLER_120_85 VGND VGND VPWR VPWR sky130_fd_sc_hd__decap_3
Xfanout62 _6622_/A VGND VGND VPWR VPWR _6654_/A sky130_fd_sc_hd__buf_2
XTAP_TAPCELL_ROW_12_426 VGND VPWR sky130_fd_sc_hd__tapvpwrvgnd_1
Xfanout73 _6462_/A VGND VGND VPWR VPWR _6558_/A sky130_fd_sc_hd__buf_1
XFILLER_22_280 VGND VGND VPWR VPWR sky130_fd_sc_hd__decap_3
XFILLER_10_442 VGND VGND VPWR VPWR sky130_fd_sc_hd__decap_3
XFILLER_13_72 VGND VGND VPWR VPWR sky130_fd_sc_hd__decap_3
XFILLER_6_424 VGND VGND VPWR VPWR sky130_fd_sc_hd__decap_3
XFILLER_13_94 VGND VGND VPWR VPWR sky130_fd_sc_hd__decap_3
XTAP_TAPCELL_ROW_79_1291 VGND VPWR sky130_fd_sc_hd__tapvpwrvgnd_1
XFILLER_89_65 VGND VGND VPWR VPWR sky130_fd_sc_hd__decap_3
XFILLER_108_385 VGND VGND VPWR VPWR sky130_fd_sc_hd__decap_3
XFILLER_89_76 VGND VGND VPWR VPWR sky130_fd_sc_hd__decap_3
XFILLER_108_396 VGND VGND VPWR VPWR sky130_fd_sc_hd__decap_3
XFILLER_97_718 VGND VGND VPWR VPWR sky130_fd_sc_hd__decap_3
XFILLER_2_641 VGND VGND VPWR VPWR sky130_fd_sc_hd__decap_3
XFILLER_97_729 VGND VGND VPWR VPWR sky130_fd_sc_hd__decap_3
XFILLER_2_663 VGND VGND VPWR VPWR sky130_fd_sc_hd__decap_3
XFILLER_96_217 VGND VGND VPWR VPWR sky130_fd_sc_hd__decap_3
XFILLER_123_377 VGND VGND VPWR VPWR sky130_fd_sc_hd__fill_1
XFILLER_111_528 VGND VGND VPWR VPWR sky130_fd_sc_hd__decap_3
XFILLER_123_399 VGND VGND VPWR VPWR sky130_fd_sc_hd__decap_3
XFILLER_49_111 VGND VGND VPWR VPWR sky130_fd_sc_hd__fill_1
XFILLER_2_696 VGND VGND VPWR VPWR sky130_fd_sc_hd__decap_3
XFILLER_65_604 VGND VGND VPWR VPWR sky130_fd_sc_hd__decap_3
XFILLER_92_401 VGND VGND VPWR VPWR sky130_fd_sc_hd__decap_3
XFILLER_65_626 VGND VGND VPWR VPWR sky130_fd_sc_hd__decap_3
XFILLER_77_497 VGND VGND VPWR VPWR sky130_fd_sc_hd__decap_3
XFILLER_37_328 VGND VGND VPWR VPWR sky130_fd_sc_hd__decap_3
XFILLER_65_659 VGND VGND VPWR VPWR sky130_fd_sc_hd__decap_3
XFILLER_92_456 VGND VGND VPWR VPWR sky130_fd_sc_hd__decap_3
XFILLER_80_607 VGND VGND VPWR VPWR sky130_fd_sc_hd__decap_3
XFILLER_64_158 VGND VGND VPWR VPWR sky130_fd_sc_hd__decap_3
XFILLER_52_309 VGND VGND VPWR VPWR sky130_fd_sc_hd__decap_3
XFILLER_18_575 VGND VGND VPWR VPWR sky130_fd_sc_hd__decap_3
XFILLER_45_361 VGND VGND VPWR VPWR sky130_fd_sc_hd__decap_3
XFILLER_33_523 VGND VGND VPWR VPWR sky130_fd_sc_hd__decap_3
XFILLER_60_320 VGND VGND VPWR VPWR sky130_fd_sc_hd__decap_3
XFILLER_60_353 VGND VGND VPWR VPWR sky130_fd_sc_hd__decap_3
XFILLER_33_567 VGND VGND VPWR VPWR sky130_fd_sc_hd__fill_1
X_3800_ _6861_/Q _3891_/A2 _3878_/B1 _6901_/Q _3799_/X VGND VGND VPWR VPWR _3800_/X
+ sky130_fd_sc_hd__a221o_2
XFILLER_33_578 VGND VGND VPWR VPWR sky130_fd_sc_hd__decap_3
XFILLER_21_718 VGND VGND VPWR VPWR sky130_fd_sc_hd__decap_3
X_4780_ _4779_/X _4447_/B _4647_/C VGND VGND VPWR VPWR _4780_/Y sky130_fd_sc_hd__a21oi_2
XFILLER_21_729 VGND VGND VPWR VPWR sky130_fd_sc_hd__decap_3
XFILLER_20_228 VGND VGND VPWR VPWR sky130_fd_sc_hd__decap_3
X_3731_ _6758_/Q _3884_/B1 _3883_/B1 _6770_/Q VGND VGND VPWR VPWR _3731_/X sky130_fd_sc_hd__a22o_2
XFILLER_119_606 VGND VGND VPWR VPWR sky130_fd_sc_hd__decap_3
XFILLER_119_617 VGND VGND VPWR VPWR sky130_fd_sc_hd__decap_3
XFILLER_9_251 VGND VGND VPWR VPWR sky130_fd_sc_hd__decap_3
X_6450_ _6643_/A VGND VGND VPWR VPWR _6450_/Y sky130_fd_sc_hd__inv_2
XFILLER_9_284 VGND VGND VPWR VPWR sky130_fd_sc_hd__decap_3
Xclkload10 _7378_/CLK VGND VGND VPWR VPWR clkload10/Y sky130_fd_sc_hd__bufinv_16
Xclkload21 _7401_/CLK VGND VGND VPWR VPWR clkload21/Y sky130_fd_sc_hd__clkinv_2
Xclkload32 _7392_/CLK VGND VGND VPWR VPWR clkload32/Y sky130_fd_sc_hd__inv_4
X_6381_ _6569_/A VGND VGND VPWR VPWR _6381_/Y sky130_fd_sc_hd__inv_2
X_3593_ _3620_/A _4292_/B _3592_/X VGND VGND VPWR VPWR _3594_/B sky130_fd_sc_hd__a21o_2
XFILLER_114_300 VGND VGND VPWR VPWR sky130_fd_sc_hd__decap_3
XFILLER_88_707 VGND VGND VPWR VPWR sky130_fd_sc_hd__decap_3
XPHY_EDGE_ROW_10_Left_134 VGND VGND VPWR VPWR sky130_fd_sc_hd__decap_3
X_4214_ _7228_/Q _4421_/A2 _4348_/A2 _7164_/Q _4213_/X VGND VGND VPWR VPWR _4214_/X
+ sky130_fd_sc_hd__a221o_2
X_7002_ _7370_/CLK _7002_/D _6282_/Y VGND VGND VPWR VPWR _7002_/Q sky130_fd_sc_hd__dfrtp_2
XFILLER_87_228 VGND VGND VPWR VPWR sky130_fd_sc_hd__decap_3
XFILLER_102_539 VGND VGND VPWR VPWR sky130_fd_sc_hd__decap_3
XFILLER_87_239 VGND VGND VPWR VPWR sky130_fd_sc_hd__decap_3
X_5194_ _5194_/A _5207_/B VGND VGND VPWR VPWR _7231_/D sky130_fd_sc_hd__and2_2
XFILLER_68_442 VGND VGND VPWR VPWR sky130_fd_sc_hd__decap_3
X_4145_ _7298_/Q _4429_/A2 _4144_/X _4347_/C1 VGND VGND VPWR VPWR _4145_/X sky130_fd_sc_hd__a211o_2
XFILLER_56_604 VGND VGND VPWR VPWR sky130_fd_sc_hd__decap_3
XFILLER_68_475 VGND VGND VPWR VPWR sky130_fd_sc_hd__fill_1
XFILLER_68_486 VGND VGND VPWR VPWR sky130_fd_sc_hd__decap_3
XFILLER_110_572 VGND VGND VPWR VPWR sky130_fd_sc_hd__decap_3
XFILLER_56_637 VGND VGND VPWR VPWR sky130_fd_sc_hd__decap_3
XFILLER_56_648 VGND VGND VPWR VPWR sky130_fd_sc_hd__decap_3
XFILLER_28_339 VGND VGND VPWR VPWR sky130_fd_sc_hd__decap_3
X_4076_ _7147_/Q _4434_/B1 _4436_/B1 _7179_/Q VGND VGND VPWR VPWR _4076_/X sky130_fd_sc_hd__a22o_2
XFILLER_83_467 VGND VGND VPWR VPWR sky130_fd_sc_hd__decap_3
XFILLER_71_607 VGND VGND VPWR VPWR sky130_fd_sc_hd__decap_3
XFILLER_55_169 VGND VGND VPWR VPWR sky130_fd_sc_hd__fill_2
XFILLER_71_629 VGND VGND VPWR VPWR sky130_fd_sc_hd__decap_3
XFILLER_36_350 VGND VGND VPWR VPWR sky130_fd_sc_hd__decap_3
XTAP_TAPCELL_ROW_104_1616 VGND VPWR sky130_fd_sc_hd__tapvpwrvgnd_1
XFILLER_64_681 VGND VGND VPWR VPWR sky130_fd_sc_hd__decap_3
XFILLER_51_320 VGND VGND VPWR VPWR sky130_fd_sc_hd__decap_3
XFILLER_34_49 VGND VGND VPWR VPWR sky130_fd_sc_hd__fill_1
XFILLER_12_707 VGND VGND VPWR VPWR sky130_fd_sc_hd__decap_3
XFILLER_24_578 VGND VGND VPWR VPWR sky130_fd_sc_hd__decap_3
XFILLER_24_589 VGND VGND VPWR VPWR sky130_fd_sc_hd__decap_3
X_4978_ _4910_/A _4973_/X _4975_/Y _6993_/D _4997_/A1 VGND VGND VPWR VPWR _4978_/X
+ sky130_fd_sc_hd__a32o_2
XFILLER_11_239 VGND VGND VPWR VPWR sky130_fd_sc_hd__fill_2
XTAP_TAPCELL_ROW_63_1081 VGND VPWR sky130_fd_sc_hd__tapvpwrvgnd_1
X_6717_ _7371_/CLK _6717_/D VGND VGND VPWR VPWR _6717_/Q sky130_fd_sc_hd__dfxtp_2
XTAP_TAPCELL_ROW_63_1092 VGND VPWR sky130_fd_sc_hd__tapvpwrvgnd_1
Xclkload4 clkload4/A VGND VGND VPWR VPWR clkload4/X sky130_fd_sc_hd__clkbuf_1
X_6648_ _6654_/A VGND VGND VPWR VPWR _6648_/Y sky130_fd_sc_hd__inv_2
XFILLER_109_127 VGND VGND VPWR VPWR sky130_fd_sc_hd__decap_3
XFILLER_109_138 VGND VGND VPWR VPWR sky130_fd_sc_hd__decap_3
XFILLER_119_6 VGND VGND VPWR VPWR sky130_fd_sc_hd__decap_3
X_6579_ _6581_/A VGND VGND VPWR VPWR _6579_/Y sky130_fd_sc_hd__inv_2
XFILLER_118_672 VGND VGND VPWR VPWR sky130_fd_sc_hd__decap_3
XFILLER_3_416 VGND VGND VPWR VPWR sky130_fd_sc_hd__decap_3
XTAP_TAPCELL_ROW_115_1756 VGND VPWR sky130_fd_sc_hd__tapvpwrvgnd_1
XTAP_TAPCELL_ROW_115_1767 VGND VPWR sky130_fd_sc_hd__tapvpwrvgnd_1
XFILLER_105_333 VGND VGND VPWR VPWR sky130_fd_sc_hd__decap_3
XFILLER_1_6 VGND VGND VPWR VPWR sky130_fd_sc_hd__decap_3
XFILLER_79_718 VGND VGND VPWR VPWR sky130_fd_sc_hd__decap_3
XFILLER_59_35 VGND VGND VPWR VPWR sky130_fd_sc_hd__fill_1
XFILLER_105_355 VGND VGND VPWR VPWR sky130_fd_sc_hd__decap_3
XFILLER_79_729 VGND VGND VPWR VPWR sky130_fd_sc_hd__decap_3
XFILLER_78_206 VGND VGND VPWR VPWR sky130_fd_sc_hd__decap_3
XFILLER_78_239 VGND VGND VPWR VPWR sky130_fd_sc_hd__decap_3
XFILLER_59_420 VGND VGND VPWR VPWR sky130_fd_sc_hd__decap_3
XFILLER_120_347 VGND VGND VPWR VPWR sky130_fd_sc_hd__decap_3
XFILLER_59_442 VGND VGND VPWR VPWR sky130_fd_sc_hd__decap_3
XFILLER_93_209 VGND VGND VPWR VPWR sky130_fd_sc_hd__decap_3
XFILLER_115_52 VGND VGND VPWR VPWR sky130_fd_sc_hd__decap_3
XFILLER_75_12 VGND VGND VPWR VPWR sky130_fd_sc_hd__decap_3
XFILLER_47_604 VGND VGND VPWR VPWR sky130_fd_sc_hd__decap_3
XFILLER_115_63 VGND VGND VPWR VPWR sky130_fd_sc_hd__decap_3
XFILLER_101_561 VGND VGND VPWR VPWR sky130_fd_sc_hd__decap_3
XFILLER_47_626 VGND VGND VPWR VPWR sky130_fd_sc_hd__decap_3
XFILLER_115_96 VGND VGND VPWR VPWR sky130_fd_sc_hd__decap_3
XFILLER_46_114 VGND VGND VPWR VPWR sky130_fd_sc_hd__decap_3
XFILLER_101_594 VGND VGND VPWR VPWR sky130_fd_sc_hd__decap_3
XFILLER_74_445 VGND VGND VPWR VPWR sky130_fd_sc_hd__decap_3
XFILLER_47_659 VGND VGND VPWR VPWR sky130_fd_sc_hd__decap_3
XFILLER_34_309 VGND VGND VPWR VPWR sky130_fd_sc_hd__decap_3
XFILLER_62_629 VGND VGND VPWR VPWR sky130_fd_sc_hd__decap_3
XFILLER_27_361 VGND VGND VPWR VPWR sky130_fd_sc_hd__decap_3
XTAP_TAPCELL_ROW_45_849 VGND VPWR sky130_fd_sc_hd__tapvpwrvgnd_1
XFILLER_91_11 VGND VGND VPWR VPWR sky130_fd_sc_hd__decap_3
XFILLER_42_320 VGND VGND VPWR VPWR sky130_fd_sc_hd__decap_3
XFILLER_70_640 VGND VGND VPWR VPWR sky130_fd_sc_hd__decap_3
XFILLER_15_556 VGND VGND VPWR VPWR sky130_fd_sc_hd__decap_3
XFILLER_70_651 VGND VGND VPWR VPWR sky130_fd_sc_hd__decap_3
XFILLER_15_567 VGND VGND VPWR VPWR sky130_fd_sc_hd__decap_3
XFILLER_70_684 VGND VGND VPWR VPWR sky130_fd_sc_hd__decap_3
XFILLER_42_375 VGND VGND VPWR VPWR sky130_fd_sc_hd__decap_3
XTAP_TAPCELL_ROW_25_595 VGND VPWR sky130_fd_sc_hd__tapvpwrvgnd_1
XFILLER_30_559 VGND VGND VPWR VPWR sky130_fd_sc_hd__decap_3
XFILLER_7_700 VGND VGND VPWR VPWR sky130_fd_sc_hd__decap_3
XFILLER_10_283 VGND VGND VPWR VPWR sky130_fd_sc_hd__decap_3
XFILLER_109_650 VGND VGND VPWR VPWR sky130_fd_sc_hd__decap_3
XFILLER_115_108 VGND VGND VPWR VPWR sky130_fd_sc_hd__decap_3
XFILLER_40_81 VGND VGND VPWR VPWR sky130_fd_sc_hd__decap_3
XFILLER_109_694 VGND VGND VPWR VPWR sky130_fd_sc_hd__decap_3
XFILLER_123_152 VGND VGND VPWR VPWR sky130_fd_sc_hd__fill_1
XTAP_TAPCELL_ROW_90_1439 VGND VPWR sky130_fd_sc_hd__tapvpwrvgnd_1
XFILLER_69_228 VGND VGND VPWR VPWR sky130_fd_sc_hd__fill_1
XFILLER_111_314 VGND VGND VPWR VPWR sky130_fd_sc_hd__decap_3
XFILLER_97_559 VGND VGND VPWR VPWR sky130_fd_sc_hd__fill_1
XFILLER_38_604 VGND VGND VPWR VPWR sky130_fd_sc_hd__decap_3
XFILLER_65_401 VGND VGND VPWR VPWR sky130_fd_sc_hd__decap_3
XFILLER_93_721 VGND VGND VPWR VPWR sky130_fd_sc_hd__decap_3
XFILLER_38_637 VGND VGND VPWR VPWR sky130_fd_sc_hd__decap_3
XFILLER_93_732 VGND VGND VPWR VPWR sky130_fd_sc_hd__decap_3
XFILLER_65_434 VGND VGND VPWR VPWR sky130_fd_sc_hd__decap_3
XFILLER_38_648 VGND VGND VPWR VPWR sky130_fd_sc_hd__decap_3
XFILLER_92_253 VGND VGND VPWR VPWR sky130_fd_sc_hd__decap_3
XFILLER_65_467 VGND VGND VPWR VPWR sky130_fd_sc_hd__decap_3
XFILLER_37_158 VGND VGND VPWR VPWR sky130_fd_sc_hd__fill_1
XFILLER_37_169 VGND VGND VPWR VPWR sky130_fd_sc_hd__decap_3
XFILLER_53_629 VGND VGND VPWR VPWR sky130_fd_sc_hd__decap_3
XFILLER_18_361 VGND VGND VPWR VPWR sky130_fd_sc_hd__decap_3
XFILLER_92_286 VGND VGND VPWR VPWR sky130_fd_sc_hd__decap_3
XFILLER_46_681 VGND VGND VPWR VPWR sky130_fd_sc_hd__decap_3
X_4901_ _4901_/A0 _4899_/X _4979_/S VGND VGND VPWR VPWR _7268_/D sky130_fd_sc_hd__mux2_2
XFILLER_18_394 VGND VGND VPWR VPWR sky130_fd_sc_hd__decap_3
XFILLER_33_331 VGND VGND VPWR VPWR sky130_fd_sc_hd__decap_3
XFILLER_61_662 VGND VGND VPWR VPWR sky130_fd_sc_hd__decap_3
XFILLER_61_673 VGND VGND VPWR VPWR sky130_fd_sc_hd__decap_3
X_4832_ _4832_/A _5657_/A VGND VGND VPWR VPWR _4832_/X sky130_fd_sc_hd__or2_2
XFILLER_60_183 VGND VGND VPWR VPWR sky130_fd_sc_hd__decap_3
X_4763_ _4762_/A _4762_/B _4829_/A VGND VGND VPWR VPWR _4763_/X sky130_fd_sc_hd__a21o_2
X_6502_ _6566_/A VGND VGND VPWR VPWR _6502_/Y sky130_fd_sc_hd__inv_2
X_3714_ _3735_/A _3741_/B _3746_/C VGND VGND VPWR VPWR _3714_/X sky130_fd_sc_hd__and3_2
X_4694_ _7008_/Q _4728_/A VGND VGND VPWR VPWR _4694_/Y sky130_fd_sc_hd__nor2_2
XFILLER_119_469 VGND VGND VPWR VPWR sky130_fd_sc_hd__decap_3
XFILLER_107_609 VGND VGND VPWR VPWR sky130_fd_sc_hd__decap_3
X_6433_ _6635_/A VGND VGND VPWR VPWR _6433_/Y sky130_fd_sc_hd__inv_2
X_3645_ hold944/X _3857_/A2 _4664_/B VGND VGND VPWR VPWR _7406_/D sky130_fd_sc_hd__a21o_2
XFILLER_20_29 VGND VGND VPWR VPWR sky130_fd_sc_hd__decap_3
XFILLER_115_620 VGND VGND VPWR VPWR sky130_fd_sc_hd__decap_3
X_3576_ _7252_/Q _3358_/X _3377_/X _7220_/Q _3575_/X VGND VGND VPWR VPWR _3591_/B
+ sky130_fd_sc_hd__a221oi_2
X_6364_ _6366_/A VGND VGND VPWR VPWR _6364_/Y sky130_fd_sc_hd__inv_2
XFILLER_115_653 VGND VGND VPWR VPWR sky130_fd_sc_hd__decap_3
X_5315_ _5315_/A0 _4878_/X _5315_/S VGND VGND VPWR VPWR _7173_/D sky130_fd_sc_hd__mux2_2
XFILLER_114_141 VGND VGND VPWR VPWR sky130_fd_sc_hd__fill_1
X_6295_ _6635_/A VGND VGND VPWR VPWR _6295_/Y sky130_fd_sc_hd__inv_2
XFILLER_0_419 VGND VGND VPWR VPWR sky130_fd_sc_hd__fill_1
XFILLER_115_697 VGND VGND VPWR VPWR sky130_fd_sc_hd__decap_3
XFILLER_114_185 VGND VGND VPWR VPWR sky130_fd_sc_hd__decap_3
XFILLER_102_325 VGND VGND VPWR VPWR sky130_fd_sc_hd__fill_2
XFILLER_88_559 VGND VGND VPWR VPWR sky130_fd_sc_hd__decap_3
XPHY_EDGE_ROW_89_Right_89 VGND VGND VPWR VPWR sky130_fd_sc_hd__decap_3
XFILLER_102_358 VGND VGND VPWR VPWR sky130_fd_sc_hd__decap_3
XFILLER_29_604 VGND VGND VPWR VPWR sky130_fd_sc_hd__decap_3
X_5177_ _5177_/A _5200_/B VGND VGND VPWR VPWR _7239_/D sky130_fd_sc_hd__and2_2
XFILLER_84_710 VGND VGND VPWR VPWR sky130_fd_sc_hd__decap_3
XTAP_TAPCELL_ROW_110_1697 VGND VPWR sky130_fd_sc_hd__tapvpwrvgnd_1
XFILLER_96_581 VGND VGND VPWR VPWR sky130_fd_sc_hd__decap_3
XFILLER_29_626 VGND VGND VPWR VPWR sky130_fd_sc_hd__decap_3
XFILLER_96_592 VGND VGND VPWR VPWR sky130_fd_sc_hd__decap_3
XFILLER_68_283 VGND VGND VPWR VPWR sky130_fd_sc_hd__decap_3
X_4128_ _7331_/Q _3956_/S _4428_/B1 _7139_/Q VGND VGND VPWR VPWR _4128_/X sky130_fd_sc_hd__a22o_2
XFILLER_29_659 VGND VGND VPWR VPWR sky130_fd_sc_hd__decap_3
XFILLER_83_231 VGND VGND VPWR VPWR sky130_fd_sc_hd__decap_3
XFILLER_28_147 VGND VGND VPWR VPWR sky130_fd_sc_hd__fill_1
XFILLER_44_618 VGND VGND VPWR VPWR sky130_fd_sc_hd__decap_3
XFILLER_16_309 VGND VGND VPWR VPWR sky130_fd_sc_hd__decap_3
X_4059_ _7276_/Q _4431_/A2 _4056_/X _4058_/X VGND VGND VPWR VPWR _4059_/X sky130_fd_sc_hd__a211o_2
XFILLER_83_264 VGND VGND VPWR VPWR sky130_fd_sc_hd__decap_3
XFILLER_56_489 VGND VGND VPWR VPWR sky130_fd_sc_hd__decap_3
XFILLER_71_426 VGND VGND VPWR VPWR sky130_fd_sc_hd__decap_3
XTAP_TAPCELL_ROW_65_1110 VGND VPWR sky130_fd_sc_hd__tapvpwrvgnd_1
XFILLER_71_437 VGND VGND VPWR VPWR sky130_fd_sc_hd__decap_3
XFILLER_52_640 VGND VGND VPWR VPWR sky130_fd_sc_hd__decap_3
XFILLER_24_331 VGND VGND VPWR VPWR sky130_fd_sc_hd__decap_3
XFILLER_52_651 VGND VGND VPWR VPWR sky130_fd_sc_hd__decap_3
XTAP_TAPCELL_ROW_42_808 VGND VPWR sky130_fd_sc_hd__tapvpwrvgnd_1
XFILLER_101_32 VGND VGND VPWR VPWR sky130_fd_sc_hd__decap_3
XTAP_TAPCELL_ROW_42_819 VGND VPWR sky130_fd_sc_hd__tapvpwrvgnd_1
XFILLER_52_684 VGND VGND VPWR VPWR sky130_fd_sc_hd__decap_3
XFILLER_101_54 VGND VGND VPWR VPWR sky130_fd_sc_hd__fill_2
XPHY_EDGE_ROW_98_Right_98 VGND VGND VPWR VPWR sky130_fd_sc_hd__decap_3
XFILLER_51_172 VGND VGND VPWR VPWR sky130_fd_sc_hd__decap_3
XFILLER_101_76 VGND VGND VPWR VPWR sky130_fd_sc_hd__decap_3
XFILLER_12_559 VGND VGND VPWR VPWR sky130_fd_sc_hd__decap_3
XFILLER_8_519 VGND VGND VPWR VPWR sky130_fd_sc_hd__decap_3
XTAP_TAPCELL_ROW_22_554 VGND VPWR sky130_fd_sc_hd__tapvpwrvgnd_1
XFILLER_20_581 VGND VGND VPWR VPWR sky130_fd_sc_hd__decap_3
XFILLER_20_592 VGND VGND VPWR VPWR sky130_fd_sc_hd__decap_3
XFILLER_117_3 VGND VGND VPWR VPWR sky130_fd_sc_hd__decap_3
XFILLER_4_725 VGND VGND VPWR VPWR sky130_fd_sc_hd__decap_3
XFILLER_3_202 VGND VGND VPWR VPWR sky130_fd_sc_hd__decap_3
XFILLER_118_480 VGND VGND VPWR VPWR sky130_fd_sc_hd__decap_3
XFILLER_106_631 VGND VGND VPWR VPWR sky130_fd_sc_hd__decap_3
XTAP_TAPCELL_ROW_76_1250 VGND VPWR sky130_fd_sc_hd__tapvpwrvgnd_1
XTAP_TAPCELL_ROW_76_1261 VGND VPWR sky130_fd_sc_hd__tapvpwrvgnd_1
XFILLER_106_675 VGND VGND VPWR VPWR sky130_fd_sc_hd__decap_3
XFILLER_121_612 VGND VGND VPWR VPWR sky130_fd_sc_hd__decap_3
XFILLER_79_537 VGND VGND VPWR VPWR sky130_fd_sc_hd__decap_3
XFILLER_121_623 VGND VGND VPWR VPWR sky130_fd_sc_hd__decap_3
XFILLER_120_100 VGND VGND VPWR VPWR sky130_fd_sc_hd__decap_3
XFILLER_121_656 VGND VGND VPWR VPWR sky130_fd_sc_hd__decap_3
XFILLER_86_55 VGND VGND VPWR VPWR sky130_fd_sc_hd__decap_3
XFILLER_87_570 VGND VGND VPWR VPWR sky130_fd_sc_hd__decap_3
XFILLER_86_77 VGND VGND VPWR VPWR sky130_fd_sc_hd__decap_3
XFILLER_86_88 VGND VGND VPWR VPWR sky130_fd_sc_hd__fill_2
XFILLER_75_721 VGND VGND VPWR VPWR sky130_fd_sc_hd__decap_3
XFILLER_75_732 VGND VGND VPWR VPWR sky130_fd_sc_hd__decap_3
XFILLER_47_467 VGND VGND VPWR VPWR sky130_fd_sc_hd__decap_3
XFILLER_19_93 VGND VGND VPWR VPWR sky130_fd_sc_hd__decap_3
XFILLER_74_253 VGND VGND VPWR VPWR sky130_fd_sc_hd__decap_3
XFILLER_90_713 VGND VGND VPWR VPWR sky130_fd_sc_hd__decap_3
XFILLER_19_169 VGND VGND VPWR VPWR sky130_fd_sc_hd__decap_3
XFILLER_35_629 VGND VGND VPWR VPWR sky130_fd_sc_hd__decap_3
XFILLER_28_681 VGND VGND VPWR VPWR sky130_fd_sc_hd__decap_3
XTAP_TAPCELL_ROW_2_290 VGND VPWR sky130_fd_sc_hd__tapvpwrvgnd_1
XFILLER_62_448 VGND VGND VPWR VPWR sky130_fd_sc_hd__decap_3
XFILLER_43_662 VGND VGND VPWR VPWR sky130_fd_sc_hd__decap_3
XFILLER_43_673 VGND VGND VPWR VPWR sky130_fd_sc_hd__decap_3
XFILLER_30_312 VGND VGND VPWR VPWR sky130_fd_sc_hd__fill_2
XFILLER_42_194 VGND VGND VPWR VPWR sky130_fd_sc_hd__fill_2
XFILLER_30_334 VGND VGND VPWR VPWR sky130_fd_sc_hd__decap_3
XFILLER_30_389 VGND VGND VPWR VPWR sky130_fd_sc_hd__decap_3
XFILLER_11_570 VGND VGND VPWR VPWR sky130_fd_sc_hd__decap_3
XFILLER_51_80 VGND VGND VPWR VPWR sky130_fd_sc_hd__fill_2
XFILLER_7_585 VGND VGND VPWR VPWR sky130_fd_sc_hd__decap_3
XFILLER_109_491 VGND VGND VPWR VPWR sky130_fd_sc_hd__decap_3
X_3361_ _3386_/A _3386_/B VGND VGND VPWR VPWR _3376_/B sky130_fd_sc_hd__and2_2
XFILLER_112_601 VGND VGND VPWR VPWR sky130_fd_sc_hd__decap_3
X_5100_ _5100_/A _5100_/B VGND VGND VPWR VPWR _5100_/Y sky130_fd_sc_hd__xnor2_2
XFILLER_112_634 VGND VGND VPWR VPWR sky130_fd_sc_hd__decap_3
XFILLER_112_645 VGND VGND VPWR VPWR sky130_fd_sc_hd__decap_3
X_5031_ _5032_/A _5031_/B VGND VGND VPWR VPWR _5031_/X sky130_fd_sc_hd__xor2_2
XFILLER_97_367 VGND VGND VPWR VPWR sky130_fd_sc_hd__decap_3
XFILLER_112_678 VGND VGND VPWR VPWR sky130_fd_sc_hd__decap_3
Xhold1208 _7252_/Q VGND VGND VPWR VPWR _5132_/A0 sky130_fd_sc_hd__dlygate4sd3_1
XFILLER_57_209 VGND VGND VPWR VPWR sky130_fd_sc_hd__decap_3
XFILLER_111_155 VGND VGND VPWR VPWR sky130_fd_sc_hd__decap_3
Xhold1219 _6704_/Q VGND VGND VPWR VPWR _5708_/A1 sky130_fd_sc_hd__dlygate4sd3_1
XFILLER_66_710 VGND VGND VPWR VPWR sky130_fd_sc_hd__decap_3
XFILLER_38_412 VGND VGND VPWR VPWR sky130_fd_sc_hd__decap_3
XFILLER_78_592 VGND VGND VPWR VPWR sky130_fd_sc_hd__decap_3
XFILLER_26_607 VGND VGND VPWR VPWR sky130_fd_sc_hd__decap_3
XFILLER_93_573 VGND VGND VPWR VPWR sky130_fd_sc_hd__decap_3
XFILLER_65_264 VGND VGND VPWR VPWR sky130_fd_sc_hd__decap_3
XFILLER_81_724 VGND VGND VPWR VPWR sky130_fd_sc_hd__decap_3
X_6982_ clkload6/A _6982_/D _6262_/Y VGND VGND VPWR VPWR _6982_/Q sky130_fd_sc_hd__dfrtp_2
XTAP_TAPCELL_ROW_0_249 VGND VPWR sky130_fd_sc_hd__tapvpwrvgnd_1
XFILLER_80_212 VGND VGND VPWR VPWR sky130_fd_sc_hd__decap_3
XFILLER_80_234 VGND VGND VPWR VPWR sky130_fd_sc_hd__decap_3
XFILLER_34_640 VGND VGND VPWR VPWR sky130_fd_sc_hd__decap_3
XFILLER_80_256 VGND VGND VPWR VPWR sky130_fd_sc_hd__decap_3
XFILLER_34_651 VGND VGND VPWR VPWR sky130_fd_sc_hd__decap_3
XFILLER_80_289 VGND VGND VPWR VPWR sky130_fd_sc_hd__decap_3
XFILLER_61_470 VGND VGND VPWR VPWR sky130_fd_sc_hd__decap_3
XFILLER_34_684 VGND VGND VPWR VPWR sky130_fd_sc_hd__decap_3
XFILLER_33_172 VGND VGND VPWR VPWR sky130_fd_sc_hd__decap_3
X_4815_ _4812_/Y _4813_/Y _4814_/Y _4779_/X VGND VGND VPWR VPWR _4815_/X sky130_fd_sc_hd__o211a_2
XFILLER_33_194 VGND VGND VPWR VPWR sky130_fd_sc_hd__decap_3
XFILLER_21_356 VGND VGND VPWR VPWR sky130_fd_sc_hd__decap_3
XFILLER_119_200 VGND VGND VPWR VPWR sky130_fd_sc_hd__decap_3
XTAP_TAPCELL_ROW_60_1051 VGND VPWR sky130_fd_sc_hd__tapvpwrvgnd_1
X_4746_ _4764_/B _4069_/B _4744_/Y _4745_/Y _4852_/A VGND VGND VPWR VPWR _4746_/X
+ sky130_fd_sc_hd__o32a_2
X_4677_ _6989_/Q _4677_/B VGND VGND VPWR VPWR _5036_/A sky130_fd_sc_hd__and2_2
XFILLER_119_277 VGND VGND VPWR VPWR sky130_fd_sc_hd__decap_3
XFILLER_107_417 VGND VGND VPWR VPWR sky130_fd_sc_hd__decap_3
X_6416_ _6544_/A VGND VGND VPWR VPWR _6416_/Y sky130_fd_sc_hd__inv_2
X_7396_ _7398_/CLK _7396_/D _6676_/Y VGND VGND VPWR VPWR _7396_/Q sky130_fd_sc_hd__dfrtp_2
XFILLER_103_9 VGND VGND VPWR VPWR sky130_fd_sc_hd__fill_2
XFILLER_1_706 VGND VGND VPWR VPWR sky130_fd_sc_hd__fill_1
XTAP_TAPCELL_ROW_112_1726 VGND VPWR sky130_fd_sc_hd__tapvpwrvgnd_1
X_6347_ _6658_/A VGND VGND VPWR VPWR _6347_/Y sky130_fd_sc_hd__inv_2
XFILLER_1_717 VGND VGND VPWR VPWR sky130_fd_sc_hd__decap_3
XFILLER_115_461 VGND VGND VPWR VPWR sky130_fd_sc_hd__decap_3
X_3559_ _3553_/X _3557_/X _3558_/X _3429_/X VGND VGND VPWR VPWR _4295_/B sky130_fd_sc_hd__o211a_2
XFILLER_103_612 VGND VGND VPWR VPWR sky130_fd_sc_hd__decap_3
XFILLER_88_312 VGND VGND VPWR VPWR sky130_fd_sc_hd__decap_3
XFILLER_103_623 VGND VGND VPWR VPWR sky130_fd_sc_hd__decap_3
X_6278_ _6278_/A VGND VGND VPWR VPWR _6278_/Y sky130_fd_sc_hd__inv_2
XFILLER_103_656 VGND VGND VPWR VPWR sky130_fd_sc_hd__decap_3
XFILLER_88_356 VGND VGND VPWR VPWR sky130_fd_sc_hd__decap_3
XFILLER_102_144 VGND VGND VPWR VPWR sky130_fd_sc_hd__fill_1
X_5229_ _5362_/C _5229_/B _5229_/C VGND VGND VPWR VPWR _5292_/S sky130_fd_sc_hd__and3b_2
XFILLER_57_721 VGND VGND VPWR VPWR sky130_fd_sc_hd__decap_3
XFILLER_102_188 VGND VGND VPWR VPWR sky130_fd_sc_hd__decap_3
XTAP_TAPCELL_ROW_71_1191 VGND VPWR sky130_fd_sc_hd__tapvpwrvgnd_1
XFILLER_57_732 VGND VGND VPWR VPWR sky130_fd_sc_hd__decap_3
XFILLER_29_423 VGND VGND VPWR VPWR sky130_fd_sc_hd__decap_3
XFILLER_56_58 VGND VGND VPWR VPWR sky130_fd_sc_hd__fill_2
XFILLER_56_253 VGND VGND VPWR VPWR sky130_fd_sc_hd__decap_3
XFILLER_72_713 VGND VGND VPWR VPWR sky130_fd_sc_hd__decap_3
XFILLER_44_404 VGND VGND VPWR VPWR sky130_fd_sc_hd__fill_2
XFILLER_29_489 VGND VGND VPWR VPWR sky130_fd_sc_hd__decap_3
XFILLER_17_629 VGND VGND VPWR VPWR sky130_fd_sc_hd__decap_3
XFILLER_84_584 VGND VGND VPWR VPWR sky130_fd_sc_hd__decap_3
XFILLER_71_201 VGND VGND VPWR VPWR sky130_fd_sc_hd__decap_3
XFILLER_44_415 VGND VGND VPWR VPWR sky130_fd_sc_hd__decap_3
XFILLER_112_20 VGND VGND VPWR VPWR sky130_fd_sc_hd__decap_3
XTAP_TAPCELL_ROW_27_613 VGND VPWR sky130_fd_sc_hd__tapvpwrvgnd_1
XFILLER_84_595 VGND VGND VPWR VPWR sky130_fd_sc_hd__decap_3
XTAP_TAPCELL_ROW_27_624 VGND VPWR sky130_fd_sc_hd__tapvpwrvgnd_1
XFILLER_44_448 VGND VGND VPWR VPWR sky130_fd_sc_hd__decap_3
XFILLER_16_139 VGND VGND VPWR VPWR sky130_fd_sc_hd__fill_1
XFILLER_112_53 VGND VGND VPWR VPWR sky130_fd_sc_hd__decap_3
XTAP_TAPCELL_ROW_55_977 VGND VPWR sky130_fd_sc_hd__tapvpwrvgnd_1
XFILLER_25_662 VGND VGND VPWR VPWR sky130_fd_sc_hd__decap_3
XTAP_TAPCELL_ROW_123_1866 VGND VPWR sky130_fd_sc_hd__tapvpwrvgnd_1
XTAP_TAPCELL_ROW_55_988 VGND VPWR sky130_fd_sc_hd__tapvpwrvgnd_1
XFILLER_31_109 VGND VGND VPWR VPWR sky130_fd_sc_hd__decap_3
XTAP_TAPCELL_ROW_123_1877 VGND VPWR sky130_fd_sc_hd__tapvpwrvgnd_1
XFILLER_25_673 VGND VGND VPWR VPWR sky130_fd_sc_hd__decap_3
XFILLER_24_150 VGND VGND VPWR VPWR sky130_fd_sc_hd__decap_3
XFILLER_52_470 VGND VGND VPWR VPWR sky130_fd_sc_hd__decap_3
XFILLER_40_610 VGND VGND VPWR VPWR sky130_fd_sc_hd__decap_3
XFILLER_12_301 VGND VGND VPWR VPWR sky130_fd_sc_hd__decap_3
XFILLER_12_312 VGND VGND VPWR VPWR sky130_fd_sc_hd__decap_3
XFILLER_24_183 VGND VGND VPWR VPWR sky130_fd_sc_hd__decap_3
XFILLER_40_643 VGND VGND VPWR VPWR sky130_fd_sc_hd__fill_1
XFILLER_40_654 VGND VGND VPWR VPWR sky130_fd_sc_hd__decap_3
XPHY_EDGE_ROW_117_Right_117 VGND VGND VPWR VPWR sky130_fd_sc_hd__decap_3
XFILLER_40_687 VGND VGND VPWR VPWR sky130_fd_sc_hd__decap_3
XFILLER_12_389 VGND VGND VPWR VPWR sky130_fd_sc_hd__decap_3
XFILLER_4_522 VGND VGND VPWR VPWR sky130_fd_sc_hd__decap_3
XFILLER_4_533 VGND VGND VPWR VPWR sky130_fd_sc_hd__decap_3
XFILLER_21_94 VGND VGND VPWR VPWR sky130_fd_sc_hd__fill_1
XFILLER_98_109 VGND VGND VPWR VPWR sky130_fd_sc_hd__decap_3
XFILLER_4_566 VGND VGND VPWR VPWR sky130_fd_sc_hd__decap_3
XFILLER_97_76 VGND VGND VPWR VPWR sky130_fd_sc_hd__decap_3
XFILLER_121_442 VGND VGND VPWR VPWR sky130_fd_sc_hd__decap_3
XTAP_TAPCELL_ROW_7_360 VGND VPWR sky130_fd_sc_hd__tapvpwrvgnd_1
XFILLER_79_378 VGND VGND VPWR VPWR sky130_fd_sc_hd__decap_3
XFILLER_39_209 VGND VGND VPWR VPWR sky130_fd_sc_hd__decap_3
XFILLER_121_464 VGND VGND VPWR VPWR sky130_fd_sc_hd__decap_3
XFILLER_94_315 VGND VGND VPWR VPWR sky130_fd_sc_hd__fill_1
XFILLER_48_710 VGND VGND VPWR VPWR sky130_fd_sc_hd__decap_3
XFILLER_121_497 VGND VGND VPWR VPWR sky130_fd_sc_hd__decap_3
XTAP_TAPCELL_ROW_89_1430 VGND VPWR sky130_fd_sc_hd__tapvpwrvgnd_1
XFILLER_75_551 VGND VGND VPWR VPWR sky130_fd_sc_hd__decap_3
XFILLER_47_253 VGND VGND VPWR VPWR sky130_fd_sc_hd__decap_3
XFILLER_63_724 VGND VGND VPWR VPWR sky130_fd_sc_hd__decap_3
XFILLER_35_426 VGND VGND VPWR VPWR sky130_fd_sc_hd__decap_3
XFILLER_62_223 VGND VGND VPWR VPWR sky130_fd_sc_hd__decap_3
XFILLER_90_554 VGND VGND VPWR VPWR sky130_fd_sc_hd__decap_3
XFILLER_46_91 VGND VGND VPWR VPWR sky130_fd_sc_hd__decap_3
XFILLER_16_640 VGND VGND VPWR VPWR sky130_fd_sc_hd__decap_3
XFILLER_62_256 VGND VGND VPWR VPWR sky130_fd_sc_hd__decap_3
XFILLER_16_651 VGND VGND VPWR VPWR sky130_fd_sc_hd__decap_3
XFILLER_90_587 VGND VGND VPWR VPWR sky130_fd_sc_hd__fill_1
XFILLER_62_278 VGND VGND VPWR VPWR sky130_fd_sc_hd__decap_3
XFILLER_90_598 VGND VGND VPWR VPWR sky130_fd_sc_hd__decap_3
XFILLER_16_684 VGND VGND VPWR VPWR sky130_fd_sc_hd__decap_3
XFILLER_15_172 VGND VGND VPWR VPWR sky130_fd_sc_hd__decap_3
XFILLER_31_632 VGND VGND VPWR VPWR sky130_fd_sc_hd__decap_3
XFILLER_31_665 VGND VGND VPWR VPWR sky130_fd_sc_hd__decap_3
XFILLER_31_676 VGND VGND VPWR VPWR sky130_fd_sc_hd__decap_3
XFILLER_30_197 VGND VGND VPWR VPWR sky130_fd_sc_hd__decap_3
XFILLER_117_715 VGND VGND VPWR VPWR sky130_fd_sc_hd__decap_3
XFILLER_7_74 VGND VGND VPWR VPWR sky130_fd_sc_hd__fill_1
X_7250_ _7355_/CLK _7250_/D _6530_/Y VGND VGND VPWR VPWR _7250_/Q sky130_fd_sc_hd__dfrtp_2
XFILLER_116_236 VGND VGND VPWR VPWR sky130_fd_sc_hd__decap_3
X_4462_ _3621_/B _3618_/X _3541_/X VGND VGND VPWR VPWR _4462_/Y sky130_fd_sc_hd__o21ai_2
XFILLER_7_393 VGND VGND VPWR VPWR sky130_fd_sc_hd__decap_3
XFILLER_89_109 VGND VGND VPWR VPWR sky130_fd_sc_hd__decap_3
X_3413_ _7155_/Q _3409_/X _3410_/X _3412_/X VGND VGND VPWR VPWR _3413_/X sky130_fd_sc_hd__a211o_2
X_4393_ _7305_/Q _4914_/S _4434_/A2 _7113_/Q _4392_/X VGND VGND VPWR VPWR _4393_/X
+ sky130_fd_sc_hd__a221o_2
X_7181_ _7406_/CLK _7181_/D _6461_/Y VGND VGND VPWR VPWR _7181_/Q sky130_fd_sc_hd__dfrtp_2
XFILLER_98_610 VGND VGND VPWR VPWR sky130_fd_sc_hd__decap_3
X_3344_ _3519_/B _5118_/D VGND VGND VPWR VPWR _3344_/Y sky130_fd_sc_hd__nor2_2
XFILLER_98_643 VGND VGND VPWR VPWR sky130_fd_sc_hd__fill_1
XFILLER_98_654 VGND VGND VPWR VPWR sky130_fd_sc_hd__decap_3
XFILLER_112_442 VGND VGND VPWR VPWR sky130_fd_sc_hd__decap_3
XFILLER_97_153 VGND VGND VPWR VPWR sky130_fd_sc_hd__fill_1
XFILLER_100_604 VGND VGND VPWR VPWR sky130_fd_sc_hd__decap_3
XFILLER_98_687 VGND VGND VPWR VPWR sky130_fd_sc_hd__decap_3
XFILLER_112_475 VGND VGND VPWR VPWR sky130_fd_sc_hd__fill_1
Xhold1005 _7266_/Q VGND VGND VPWR VPWR _4933_/A0 sky130_fd_sc_hd__dlygate4sd3_1
XFILLER_97_186 VGND VGND VPWR VPWR sky130_fd_sc_hd__fill_2
XFILLER_85_326 VGND VGND VPWR VPWR sky130_fd_sc_hd__decap_3
XFILLER_112_486 VGND VGND VPWR VPWR sky130_fd_sc_hd__decap_3
Xhold1016 _7263_/Q VGND VGND VPWR VPWR _4979_/A0 sky130_fd_sc_hd__dlygate4sd3_1
XFILLER_39_721 VGND VGND VPWR VPWR sky130_fd_sc_hd__decap_3
XFILLER_100_637 VGND VGND VPWR VPWR sky130_fd_sc_hd__decap_3
Xhold1027 _7244_/Q VGND VGND VPWR VPWR _5167_/A sky130_fd_sc_hd__dlygate4sd3_1
XFILLER_97_197 VGND VGND VPWR VPWR sky130_fd_sc_hd__decap_3
XFILLER_85_337 VGND VGND VPWR VPWR sky130_fd_sc_hd__decap_3
XFILLER_39_732 VGND VGND VPWR VPWR sky130_fd_sc_hd__decap_3
XFILLER_100_648 VGND VGND VPWR VPWR sky130_fd_sc_hd__decap_3
X_5014_ _6990_/Q _5014_/B VGND VGND VPWR VPWR _5015_/C sky130_fd_sc_hd__or2_2
Xhold1038 _7209_/Q VGND VGND VPWR VPWR _5241_/A0 sky130_fd_sc_hd__dlygate4sd3_1
XFILLER_85_348 VGND VGND VPWR VPWR sky130_fd_sc_hd__decap_3
Xhold1049 _7283_/Q VGND VGND VPWR VPWR _4595_/A sky130_fd_sc_hd__dlygate4sd3_1
XFILLER_38_253 VGND VGND VPWR VPWR sky130_fd_sc_hd__decap_3
XFILLER_54_713 VGND VGND VPWR VPWR sky130_fd_sc_hd__decap_3
XFILLER_66_584 VGND VGND VPWR VPWR sky130_fd_sc_hd__fill_1
XFILLER_93_370 VGND VGND VPWR VPWR sky130_fd_sc_hd__fill_1
XFILLER_38_286 VGND VGND VPWR VPWR sky130_fd_sc_hd__decap_3
XFILLER_53_223 VGND VGND VPWR VPWR sky130_fd_sc_hd__fill_1
XFILLER_26_437 VGND VGND VPWR VPWR sky130_fd_sc_hd__decap_3
XFILLER_53_234 VGND VGND VPWR VPWR sky130_fd_sc_hd__decap_3
X_6965_ _6965_/CLK _6965_/D VGND VGND VPWR VPWR _6965_/Q sky130_fd_sc_hd__dfxtp_2
XFILLER_53_256 VGND VGND VPWR VPWR sky130_fd_sc_hd__decap_3
XFILLER_81_576 VGND VGND VPWR VPWR sky130_fd_sc_hd__decap_3
XFILLER_41_407 VGND VGND VPWR VPWR sky130_fd_sc_hd__decap_3
XFILLER_22_610 VGND VGND VPWR VPWR sky130_fd_sc_hd__decap_3
XTAP_TAPCELL_ROW_52_947 VGND VPWR sky130_fd_sc_hd__tapvpwrvgnd_1
X_6896_ _6965_/CLK _6896_/D VGND VGND VPWR VPWR _6896_/Q sky130_fd_sc_hd__dfxtp_2
XFILLER_22_643 VGND VGND VPWR VPWR sky130_fd_sc_hd__fill_1
XFILLER_22_654 VGND VGND VPWR VPWR sky130_fd_sc_hd__decap_3
XFILLER_21_153 VGND VGND VPWR VPWR sky130_fd_sc_hd__decap_3
XFILLER_22_687 VGND VGND VPWR VPWR sky130_fd_sc_hd__decap_3
XFILLER_21_164 VGND VGND VPWR VPWR sky130_fd_sc_hd__fill_1
XFILLER_21_175 VGND VGND VPWR VPWR sky130_fd_sc_hd__decap_3
XTAP_TAPCELL_ROW_32_682 VGND VPWR sky130_fd_sc_hd__tapvpwrvgnd_1
XFILLER_108_704 VGND VGND VPWR VPWR sky130_fd_sc_hd__decap_3
X_4729_ _5040_/S _4729_/B VGND VGND VPWR VPWR _4729_/Y sky130_fd_sc_hd__nand2_2
XFILLER_5_308 VGND VGND VPWR VPWR sky130_fd_sc_hd__decap_3
XFILLER_107_214 VGND VGND VPWR VPWR sky130_fd_sc_hd__decap_3
XFILLER_107_225 VGND VGND VPWR VPWR sky130_fd_sc_hd__fill_1
XPHY_EDGE_ROW_2_Left_126 VGND VGND VPWR VPWR sky130_fd_sc_hd__decap_3
XFILLER_123_707 VGND VGND VPWR VPWR sky130_fd_sc_hd__decap_3
XFILLER_107_258 VGND VGND VPWR VPWR sky130_fd_sc_hd__decap_3
XFILLER_101_6 VGND VGND VPWR VPWR sky130_fd_sc_hd__fill_1
XFILLER_123_729 VGND VGND VPWR VPWR sky130_fd_sc_hd__decap_3
Xhold850 _7082_/Q VGND VGND VPWR VPWR _7082_/D sky130_fd_sc_hd__dlygate4sd3_1
XTAP_TAPCELL_ROW_73_1220 VGND VPWR sky130_fd_sc_hd__tapvpwrvgnd_1
Xhold861 _7056_/Q VGND VGND VPWR VPWR _7056_/D sky130_fd_sc_hd__dlygate4sd3_1
X_7379_ _7380_/CLK _7379_/D _6659_/Y VGND VGND VPWR VPWR _7379_/Q sky130_fd_sc_hd__dfrtp_2
XFILLER_1_514 VGND VGND VPWR VPWR sky130_fd_sc_hd__decap_3
Xhold872 _7081_/Q VGND VGND VPWR VPWR _7081_/D sky130_fd_sc_hd__dlygate4sd3_1
XFILLER_89_632 VGND VGND VPWR VPWR sky130_fd_sc_hd__decap_3
XFILLER_107_31 VGND VGND VPWR VPWR sky130_fd_sc_hd__decap_3
Xhold883 _7064_/Q VGND VGND VPWR VPWR _7064_/D sky130_fd_sc_hd__dlygate4sd3_1
Xhold894 _7084_/Q VGND VGND VPWR VPWR _7084_/D sky130_fd_sc_hd__dlygate4sd3_1
XFILLER_1_547 VGND VGND VPWR VPWR sky130_fd_sc_hd__decap_3
XFILLER_89_665 VGND VGND VPWR VPWR sky130_fd_sc_hd__decap_3
XFILLER_89_676 VGND VGND VPWR VPWR sky130_fd_sc_hd__decap_3
XFILLER_88_153 VGND VGND VPWR VPWR sky130_fd_sc_hd__decap_3
XFILLER_67_24 VGND VGND VPWR VPWR sky130_fd_sc_hd__decap_3
XFILLER_76_304 VGND VGND VPWR VPWR sky130_fd_sc_hd__decap_3
XFILLER_103_475 VGND VGND VPWR VPWR sky130_fd_sc_hd__decap_3
XFILLER_67_57 VGND VGND VPWR VPWR sky130_fd_sc_hd__decap_3
XFILLER_76_326 VGND VGND VPWR VPWR sky130_fd_sc_hd__decap_3
XFILLER_88_197 VGND VGND VPWR VPWR sky130_fd_sc_hd__decap_3
XFILLER_29_220 VGND VGND VPWR VPWR sky130_fd_sc_hd__decap_3
XFILLER_91_307 VGND VGND VPWR VPWR sky130_fd_sc_hd__decap_3
XFILLER_123_41 VGND VGND VPWR VPWR sky130_fd_sc_hd__fill_2
XFILLER_123_63 VGND VGND VPWR VPWR sky130_fd_sc_hd__decap_3
XFILLER_45_724 VGND VGND VPWR VPWR sky130_fd_sc_hd__decap_3
XFILLER_72_521 VGND VGND VPWR VPWR sky130_fd_sc_hd__decap_3
XFILLER_123_85 VGND VGND VPWR VPWR sky130_fd_sc_hd__decap_3
XFILLER_83_45 VGND VGND VPWR VPWR sky130_fd_sc_hd__decap_3
XFILLER_44_234 VGND VGND VPWR VPWR sky130_fd_sc_hd__decap_3
XFILLER_72_554 VGND VGND VPWR VPWR sky130_fd_sc_hd__fill_1
XFILLER_60_716 VGND VGND VPWR VPWR sky130_fd_sc_hd__decap_3
XFILLER_44_267 VGND VGND VPWR VPWR sky130_fd_sc_hd__fill_1
XFILLER_83_89 VGND VGND VPWR VPWR sky130_fd_sc_hd__fill_2
XFILLER_72_587 VGND VGND VPWR VPWR sky130_fd_sc_hd__fill_1
XTAP_TAPCELL_ROW_84_1360 VGND VPWR sky130_fd_sc_hd__tapvpwrvgnd_1
XFILLER_72_598 VGND VGND VPWR VPWR sky130_fd_sc_hd__decap_3
XFILLER_25_481 VGND VGND VPWR VPWR sky130_fd_sc_hd__decap_3
XFILLER_16_72 VGND VGND VPWR VPWR sky130_fd_sc_hd__decap_3
XFILLER_13_632 VGND VGND VPWR VPWR sky130_fd_sc_hd__decap_3
XFILLER_9_603 VGND VGND VPWR VPWR sky130_fd_sc_hd__decap_3
XFILLER_13_665 VGND VGND VPWR VPWR sky130_fd_sc_hd__decap_3
XFILLER_13_676 VGND VGND VPWR VPWR sky130_fd_sc_hd__decap_3
XFILLER_12_153 VGND VGND VPWR VPWR sky130_fd_sc_hd__decap_3
XFILLER_9_647 VGND VGND VPWR VPWR sky130_fd_sc_hd__decap_3
XFILLER_40_495 VGND VGND VPWR VPWR sky130_fd_sc_hd__decap_3
XFILLER_12_197 VGND VGND VPWR VPWR sky130_fd_sc_hd__fill_1
XFILLER_66_9 VGND VGND VPWR VPWR sky130_fd_sc_hd__decap_3
XTAP_TAPCELL_ROW_10_398 VGND VPWR sky130_fd_sc_hd__tapvpwrvgnd_1
XFILLER_4_330 VGND VGND VPWR VPWR sky130_fd_sc_hd__decap_3
XFILLER_114_707 VGND VGND VPWR VPWR sky130_fd_sc_hd__decap_3
XFILLER_99_429 VGND VGND VPWR VPWR sky130_fd_sc_hd__decap_3
XFILLER_113_228 VGND VGND VPWR VPWR sky130_fd_sc_hd__decap_3
XFILLER_106_280 VGND VGND VPWR VPWR sky130_fd_sc_hd__decap_3
XFILLER_79_131 VGND VGND VPWR VPWR sky130_fd_sc_hd__decap_3
XFILLER_67_304 VGND VGND VPWR VPWR sky130_fd_sc_hd__decap_3
XFILLER_79_164 VGND VGND VPWR VPWR sky130_fd_sc_hd__decap_3
XFILLER_95_635 VGND VGND VPWR VPWR sky130_fd_sc_hd__decap_3
XFILLER_94_112 VGND VGND VPWR VPWR sky130_fd_sc_hd__decap_3
XFILLER_67_337 VGND VGND VPWR VPWR sky130_fd_sc_hd__decap_3
XFILLER_94_134 VGND VGND VPWR VPWR sky130_fd_sc_hd__decap_3
XFILLER_95_668 VGND VGND VPWR VPWR sky130_fd_sc_hd__decap_3
XFILLER_95_679 VGND VGND VPWR VPWR sky130_fd_sc_hd__decap_3
XFILLER_82_318 VGND VGND VPWR VPWR sky130_fd_sc_hd__fill_1
XFILLER_36_713 VGND VGND VPWR VPWR sky130_fd_sc_hd__decap_3
XFILLER_35_223 VGND VGND VPWR VPWR sky130_fd_sc_hd__fill_1
XFILLER_63_543 VGND VGND VPWR VPWR sky130_fd_sc_hd__fill_2
XFILLER_35_234 VGND VGND VPWR VPWR sky130_fd_sc_hd__decap_3
XFILLER_63_554 VGND VGND VPWR VPWR sky130_fd_sc_hd__decap_3
XFILLER_63_576 VGND VGND VPWR VPWR sky130_fd_sc_hd__fill_1
XFILLER_23_418 VGND VGND VPWR VPWR sky130_fd_sc_hd__decap_3
XFILLER_51_727 VGND VGND VPWR VPWR sky130_fd_sc_hd__fill_1
X_6750_ clkload7/A _6750_/D VGND VGND VPWR VPWR _6750_/Q sky130_fd_sc_hd__dfxtp_2
XFILLER_50_215 VGND VGND VPWR VPWR sky130_fd_sc_hd__decap_3
X_3962_ _7359_/Q _4505_/A0 _3964_/S VGND VGND VPWR VPWR _7359_/D sky130_fd_sc_hd__mux2_2
XTAP_TAPCELL_ROW_18_498 VGND VPWR sky130_fd_sc_hd__tapvpwrvgnd_1
X_5701_ _7356_/Q hold930/X _5712_/S VGND VGND VPWR VPWR _6700_/D sky130_fd_sc_hd__mux2_2
XFILLER_50_259 VGND VGND VPWR VPWR sky130_fd_sc_hd__decap_3
X_6681_ _6684_/A VGND VGND VPWR VPWR _6681_/Y sky130_fd_sc_hd__inv_2
X_3893_ _6759_/Q _3893_/A2 _3893_/B1 _6753_/Q _3892_/X VGND VGND VPWR VPWR _3893_/X
+ sky130_fd_sc_hd__a221o_2
XFILLER_31_473 VGND VGND VPWR VPWR sky130_fd_sc_hd__decap_3
X_5632_ _5632_/A VGND VGND VPWR VPWR _5633_/A sky130_fd_sc_hd__inv_2
XPHY_EDGE_ROW_75_Left_199 VGND VGND VPWR VPWR sky130_fd_sc_hd__decap_3
X_5563_ hold951/X _4909_/A _4729_/B VGND VGND VPWR VPWR _7053_/D sky130_fd_sc_hd__a21bo_2
XFILLER_117_523 VGND VGND VPWR VPWR sky130_fd_sc_hd__decap_3
X_7302_ _7374_/CLK _7302_/D _6582_/Y VGND VGND VPWR VPWR _7302_/Q sky130_fd_sc_hd__dfrtp_2
XFILLER_117_556 VGND VGND VPWR VPWR sky130_fd_sc_hd__decap_3
XFILLER_7_190 VGND VGND VPWR VPWR sky130_fd_sc_hd__decap_3
XFILLER_117_567 VGND VGND VPWR VPWR sky130_fd_sc_hd__decap_3
XFILLER_105_718 VGND VGND VPWR VPWR sky130_fd_sc_hd__decap_3
X_7233_ _7398_/CLK _7233_/D _6513_/Y VGND VGND VPWR VPWR _7233_/Q sky130_fd_sc_hd__dfrtp_2
XFILLER_105_729 VGND VGND VPWR VPWR sky130_fd_sc_hd__decap_3
X_4445_ _4813_/A _4813_/B VGND VGND VPWR VPWR _4814_/B sky130_fd_sc_hd__nor2_2
XFILLER_104_217 VGND VGND VPWR VPWR sky130_fd_sc_hd__decap_3
X_7164_ _7359_/CLK _7164_/D _6444_/Y VGND VGND VPWR VPWR _7164_/Q sky130_fd_sc_hd__dfrtp_2
X_4376_ _4376_/A _4376_/B _4376_/C _4273_/D VGND VGND VPWR VPWR _4376_/X sky130_fd_sc_hd__or4b_2
XFILLER_98_451 VGND VGND VPWR VPWR sky130_fd_sc_hd__decap_3
XFILLER_86_613 VGND VGND VPWR VPWR sky130_fd_sc_hd__decap_3
X_3327_ _3371_/A _3327_/B VGND VGND VPWR VPWR _3328_/B sky130_fd_sc_hd__nor2_2
XFILLER_58_315 VGND VGND VPWR VPWR sky130_fd_sc_hd__decap_3
X_7095_ _7354_/CLK _7095_/D _6375_/Y VGND VGND VPWR VPWR _7095_/Q sky130_fd_sc_hd__dfrtp_2
XFILLER_58_337 VGND VGND VPWR VPWR sky130_fd_sc_hd__decap_3
XFILLER_112_283 VGND VGND VPWR VPWR sky130_fd_sc_hd__fill_1
XFILLER_86_657 VGND VGND VPWR VPWR sky130_fd_sc_hd__decap_3
XFILLER_85_134 VGND VGND VPWR VPWR sky130_fd_sc_hd__decap_3
XFILLER_85_167 VGND VGND VPWR VPWR sky130_fd_sc_hd__fill_1
XFILLER_85_178 VGND VGND VPWR VPWR sky130_fd_sc_hd__decap_3
XFILLER_73_318 VGND VGND VPWR VPWR sky130_fd_sc_hd__decap_3
XFILLER_27_724 VGND VGND VPWR VPWR sky130_fd_sc_hd__decap_3
XFILLER_100_489 VGND VGND VPWR VPWR sky130_fd_sc_hd__decap_3
XFILLER_94_690 VGND VGND VPWR VPWR sky130_fd_sc_hd__decap_3
XTAP_TAPCELL_ROW_107_1658 VGND VPWR sky130_fd_sc_hd__tapvpwrvgnd_1
XTAP_TAPCELL_ROW_37_752 VGND VPWR sky130_fd_sc_hd__tapvpwrvgnd_1
XFILLER_81_340 VGND VGND VPWR VPWR sky130_fd_sc_hd__fill_2
XFILLER_26_256 VGND VGND VPWR VPWR sky130_fd_sc_hd__decap_3
XFILLER_42_716 VGND VGND VPWR VPWR sky130_fd_sc_hd__decap_3
XFILLER_14_407 VGND VGND VPWR VPWR sky130_fd_sc_hd__decap_3
XFILLER_54_587 VGND VGND VPWR VPWR sky130_fd_sc_hd__fill_1
XFILLER_26_289 VGND VGND VPWR VPWR sky130_fd_sc_hd__decap_3
X_6948_ clkload9/A _6948_/D VGND VGND VPWR VPWR _6948_/Q sky130_fd_sc_hd__dfxtp_2
XTAP_TAPCELL_ROW_120_1825 VGND VPWR sky130_fd_sc_hd__tapvpwrvgnd_1
XFILLER_41_237 VGND VGND VPWR VPWR sky130_fd_sc_hd__fill_1
XFILLER_41_248 VGND VGND VPWR VPWR sky130_fd_sc_hd__decap_3
X_6879_ _6965_/CLK _6879_/D VGND VGND VPWR VPWR _6879_/Q sky130_fd_sc_hd__dfxtp_2
XFILLER_10_613 VGND VGND VPWR VPWR sky130_fd_sc_hd__decap_3
XFILLER_22_495 VGND VGND VPWR VPWR sky130_fd_sc_hd__fill_1
XFILLER_10_657 VGND VGND VPWR VPWR sky130_fd_sc_hd__decap_3
XFILLER_108_501 VGND VGND VPWR VPWR sky130_fd_sc_hd__decap_3
XFILLER_6_628 VGND VGND VPWR VPWR sky130_fd_sc_hd__decap_3
XFILLER_108_545 VGND VGND VPWR VPWR sky130_fd_sc_hd__decap_3
XFILLER_118_41 VGND VGND VPWR VPWR sky130_fd_sc_hd__decap_3
XFILLER_108_578 VGND VGND VPWR VPWR sky130_fd_sc_hd__decap_3
XTAP_TAPCELL_ROW_118_1798 VGND VPWR sky130_fd_sc_hd__tapvpwrvgnd_1
XFILLER_108_589 VGND VGND VPWR VPWR sky130_fd_sc_hd__decap_3
XFILLER_78_12 VGND VGND VPWR VPWR sky130_fd_sc_hd__decap_3
XFILLER_118_74 VGND VGND VPWR VPWR sky130_fd_sc_hd__decap_3
XFILLER_1_311 VGND VGND VPWR VPWR sky130_fd_sc_hd__decap_3
XFILLER_123_548 VGND VGND VPWR VPWR sky130_fd_sc_hd__fill_1
XFILLER_118_85 VGND VGND VPWR VPWR sky130_fd_sc_hd__decap_3
Xhold680 _6730_/Q VGND VGND VPWR VPWR _6730_/D sky130_fd_sc_hd__dlygate4sd3_1
Xhold691 _6836_/Q VGND VGND VPWR VPWR _6836_/D sky130_fd_sc_hd__dlygate4sd3_1
XFILLER_78_78 VGND VGND VPWR VPWR sky130_fd_sc_hd__decap_3
XFILLER_110_209 VGND VGND VPWR VPWR sky130_fd_sc_hd__decap_3
XFILLER_89_473 VGND VGND VPWR VPWR sky130_fd_sc_hd__decap_3
XFILLER_103_261 VGND VGND VPWR VPWR sky130_fd_sc_hd__decap_3
XFILLER_77_635 VGND VGND VPWR VPWR sky130_fd_sc_hd__decap_3
XFILLER_76_112 VGND VGND VPWR VPWR sky130_fd_sc_hd__decap_3
XFILLER_103_272 VGND VGND VPWR VPWR sky130_fd_sc_hd__decap_3
XFILLER_49_337 VGND VGND VPWR VPWR sky130_fd_sc_hd__fill_1
XFILLER_77_668 VGND VGND VPWR VPWR sky130_fd_sc_hd__decap_3
XFILLER_49_359 VGND VGND VPWR VPWR sky130_fd_sc_hd__decap_3
XFILLER_77_679 VGND VGND VPWR VPWR sky130_fd_sc_hd__decap_3
XFILLER_92_616 VGND VGND VPWR VPWR sky130_fd_sc_hd__decap_3
XFILLER_18_713 VGND VGND VPWR VPWR sky130_fd_sc_hd__decap_3
XFILLER_17_212 VGND VGND VPWR VPWR sky130_fd_sc_hd__decap_3
XFILLER_91_137 VGND VGND VPWR VPWR sky130_fd_sc_hd__decap_3
XFILLER_27_60 VGND VGND VPWR VPWR sky130_fd_sc_hd__decap_3
XFILLER_17_234 VGND VGND VPWR VPWR sky130_fd_sc_hd__decap_3
XFILLER_27_93 VGND VGND VPWR VPWR sky130_fd_sc_hd__decap_3
XFILLER_72_362 VGND VGND VPWR VPWR sky130_fd_sc_hd__fill_2
XFILLER_33_727 VGND VGND VPWR VPWR sky130_fd_sc_hd__fill_1
XFILLER_17_278 VGND VGND VPWR VPWR sky130_fd_sc_hd__fill_2
XFILLER_45_598 VGND VGND VPWR VPWR sky130_fd_sc_hd__decap_3
XFILLER_32_237 VGND VGND VPWR VPWR sky130_fd_sc_hd__decap_3
XFILLER_60_568 VGND VGND VPWR VPWR sky130_fd_sc_hd__decap_3
XTAP_TAPCELL_ROW_15_457 VGND VPWR sky130_fd_sc_hd__tapvpwrvgnd_1
XTAP_TAPCELL_ROW_15_468 VGND VPWR sky130_fd_sc_hd__tapvpwrvgnd_1
XFILLER_9_455 VGND VGND VPWR VPWR sky130_fd_sc_hd__decap_3
XFILLER_5_650 VGND VGND VPWR VPWR sky130_fd_sc_hd__decap_3
XFILLER_99_215 VGND VGND VPWR VPWR sky130_fd_sc_hd__decap_3
XFILLER_114_526 VGND VGND VPWR VPWR sky130_fd_sc_hd__decap_3
XFILLER_99_237 VGND VGND VPWR VPWR sky130_fd_sc_hd__fill_2
XFILLER_5_694 VGND VGND VPWR VPWR sky130_fd_sc_hd__decap_3
XFILLER_114_548 VGND VGND VPWR VPWR sky130_fd_sc_hd__decap_3
X_4230_ _7227_/Q _4353_/A2 _5080_/S _7291_/Q _4229_/X VGND VGND VPWR VPWR _4230_/X
+ sky130_fd_sc_hd__a221o_2
XFILLER_99_259 VGND VGND VPWR VPWR sky130_fd_sc_hd__decap_3
XFILLER_4_182 VGND VGND VPWR VPWR sky130_fd_sc_hd__decap_3
XFILLER_68_613 VGND VGND VPWR VPWR sky130_fd_sc_hd__decap_3
X_4161_ _7265_/Q _4422_/A2 _4430_/A2 _7233_/Q _4160_/X VGND VGND VPWR VPWR _4161_/X
+ sky130_fd_sc_hd__a221o_2
XFILLER_110_710 VGND VGND VPWR VPWR sky130_fd_sc_hd__decap_3
XFILLER_122_581 VGND VGND VPWR VPWR sky130_fd_sc_hd__decap_3
XFILLER_95_432 VGND VGND VPWR VPWR sky130_fd_sc_hd__decap_3
XFILLER_122_592 VGND VGND VPWR VPWR sky130_fd_sc_hd__decap_3
XFILLER_68_657 VGND VGND VPWR VPWR sky130_fd_sc_hd__decap_3
X_4092_ _7366_/Q _4394_/B _4436_/B1 _7174_/Q _4091_/X VGND VGND VPWR VPWR _4092_/X
+ sky130_fd_sc_hd__a221o_2
XFILLER_95_487 VGND VGND VPWR VPWR sky130_fd_sc_hd__decap_3
XFILLER_67_178 VGND VGND VPWR VPWR sky130_fd_sc_hd__fill_2
XFILLER_83_638 VGND VGND VPWR VPWR sky130_fd_sc_hd__decap_3
XFILLER_67_189 VGND VGND VPWR VPWR sky130_fd_sc_hd__decap_3
XFILLER_82_137 VGND VGND VPWR VPWR sky130_fd_sc_hd__decap_3
XFILLER_76_690 VGND VGND VPWR VPWR sky130_fd_sc_hd__decap_3
XFILLER_63_340 VGND VGND VPWR VPWR sky130_fd_sc_hd__decap_3
XFILLER_36_554 VGND VGND VPWR VPWR sky130_fd_sc_hd__decap_3
XFILLER_24_716 VGND VGND VPWR VPWR sky130_fd_sc_hd__decap_3
XFILLER_91_671 VGND VGND VPWR VPWR sky130_fd_sc_hd__fill_1
X_6802_ _7403_/CLK _6802_/D VGND VGND VPWR VPWR _6802_/Q sky130_fd_sc_hd__dfxtp_2
Xplace340 _4421_/A2 VGND VGND VPWR VPWR _4430_/A2 sky130_fd_sc_hd__buf_2
XFILLER_91_682 VGND VGND VPWR VPWR sky130_fd_sc_hd__decap_3
XFILLER_36_587 VGND VGND VPWR VPWR sky130_fd_sc_hd__fill_1
XFILLER_23_204 VGND VGND VPWR VPWR sky130_fd_sc_hd__decap_3
XTAP_TAPCELL_ROW_34_711 VGND VPWR sky130_fd_sc_hd__tapvpwrvgnd_1
XFILLER_51_524 VGND VGND VPWR VPWR sky130_fd_sc_hd__decap_3
XFILLER_36_598 VGND VGND VPWR VPWR sky130_fd_sc_hd__decap_3
XFILLER_23_215 VGND VGND VPWR VPWR sky130_fd_sc_hd__decap_3
Xplace351 _4108_/B VGND VGND VPWR VPWR _4394_/B sky130_fd_sc_hd__buf_2
X_4994_ _5072_/A _4994_/A2 _4987_/A _5033_/B2 VGND VGND VPWR VPWR _4994_/X sky130_fd_sc_hd__a22o_2
Xplace362 _5159_/S VGND VGND VPWR VPWR _5140_/S sky130_fd_sc_hd__buf_2
XFILLER_90_181 VGND VGND VPWR VPWR sky130_fd_sc_hd__fill_2
Xplace373 _4799_/A VGND VGND VPWR VPWR _4832_/A sky130_fd_sc_hd__buf_2
Xplace384 _4341_/B1 VGND VGND VPWR VPWR _4348_/B1 sky130_fd_sc_hd__buf_2
X_6733_ _6978_/CLK _6733_/D VGND VGND VPWR VPWR _6733_/Q sky130_fd_sc_hd__dfxtp_2
Xplace395 _5344_/S VGND VGND VPWR VPWR _5340_/S sky130_fd_sc_hd__buf_2
XFILLER_23_259 VGND VGND VPWR VPWR sky130_fd_sc_hd__decap_3
X_3945_ _7367_/Q _4488_/A0 _3945_/S VGND VGND VPWR VPWR _7367_/D sky130_fd_sc_hd__mux2_2
XPHY_EDGE_ROW_83_Left_207 VGND VGND VPWR VPWR sky130_fd_sc_hd__decap_3
XTAP_TAPCELL_ROW_102_1588 VGND VPWR sky130_fd_sc_hd__tapvpwrvgnd_1
X_6664_ _6664_/A VGND VGND VPWR VPWR _6664_/Y sky130_fd_sc_hd__inv_2
XTAP_TAPCELL_ROW_102_1599 VGND VPWR sky130_fd_sc_hd__tapvpwrvgnd_1
X_3876_ _6858_/Q _3891_/A2 _3891_/B1 _6898_/Q VGND VGND VPWR VPWR _3876_/X sky130_fd_sc_hd__a22o_2
XFILLER_31_281 VGND VGND VPWR VPWR sky130_fd_sc_hd__decap_3
X_5615_ _5615_/A _5633_/B VGND VGND VPWR VPWR _7020_/D sky130_fd_sc_hd__or2_2
X_6595_ _6596_/A VGND VGND VPWR VPWR _6595_/Y sky130_fd_sc_hd__inv_2
XFILLER_117_331 VGND VGND VPWR VPWR sky130_fd_sc_hd__fill_1
XTAP_TAPCELL_ROW_57_1012 VGND VPWR sky130_fd_sc_hd__tapvpwrvgnd_1
XFILLER_3_609 VGND VGND VPWR VPWR sky130_fd_sc_hd__decap_3
XFILLER_105_537 VGND VGND VPWR VPWR sky130_fd_sc_hd__decap_3
X_7216_ _7354_/CLK _7216_/D _6496_/Y VGND VGND VPWR VPWR _7216_/Q sky130_fd_sc_hd__dfrtp_2
X_4428_ _7335_/Q _3945_/S _4428_/B1 _7143_/Q VGND VGND VPWR VPWR _4428_/X sky130_fd_sc_hd__a22o_2
XPHY_EDGE_ROW_92_Left_216 VGND VGND VPWR VPWR sky130_fd_sc_hd__decap_3
XFILLER_120_507 VGND VGND VPWR VPWR sky130_fd_sc_hd__decap_3
X_7147_ _7399_/CLK _7147_/D _6427_/Y VGND VGND VPWR VPWR _7147_/Q sky130_fd_sc_hd__dfrtp_2
XFILLER_48_26 VGND VGND VPWR VPWR sky130_fd_sc_hd__fill_2
XFILLER_113_570 VGND VGND VPWR VPWR sky130_fd_sc_hd__decap_3
X_4359_ _4367_/C _4367_/A _4367_/B VGND VGND VPWR VPWR _5071_/B sky130_fd_sc_hd__nand3b_2
XFILLER_59_635 VGND VGND VPWR VPWR sky130_fd_sc_hd__decap_3
XFILLER_101_721 VGND VGND VPWR VPWR sky130_fd_sc_hd__decap_3
XFILLER_98_281 VGND VGND VPWR VPWR sky130_fd_sc_hd__decap_3
XFILLER_101_732 VGND VGND VPWR VPWR sky130_fd_sc_hd__decap_3
XFILLER_86_454 VGND VGND VPWR VPWR sky130_fd_sc_hd__decap_3
XFILLER_59_668 VGND VGND VPWR VPWR sky130_fd_sc_hd__decap_3
X_7078_ _7404_/CLK _7078_/D _6358_/Y VGND VGND VPWR VPWR _7078_/Q sky130_fd_sc_hd__dfrtp_2
XFILLER_59_679 VGND VGND VPWR VPWR sky130_fd_sc_hd__decap_3
XFILLER_100_242 VGND VGND VPWR VPWR sky130_fd_sc_hd__decap_3
XFILLER_74_616 VGND VGND VPWR VPWR sky130_fd_sc_hd__decap_3
XFILLER_46_307 VGND VGND VPWR VPWR sky130_fd_sc_hd__fill_1
XFILLER_100_253 VGND VGND VPWR VPWR sky130_fd_sc_hd__decap_3
XFILLER_58_167 VGND VGND VPWR VPWR sky130_fd_sc_hd__decap_3
XFILLER_46_318 VGND VGND VPWR VPWR sky130_fd_sc_hd__decap_3
XFILLER_100_286 VGND VGND VPWR VPWR sky130_fd_sc_hd__fill_1
XFILLER_27_554 VGND VGND VPWR VPWR sky130_fd_sc_hd__fill_1
XTAP_TAPCELL_ROW_68_1152 VGND VPWR sky130_fd_sc_hd__tapvpwrvgnd_1
XFILLER_82_660 VGND VGND VPWR VPWR sky130_fd_sc_hd__decap_3
XFILLER_54_351 VGND VGND VPWR VPWR sky130_fd_sc_hd__decap_3
XFILLER_42_513 VGND VGND VPWR VPWR sky130_fd_sc_hd__fill_2
XFILLER_27_587 VGND VGND VPWR VPWR sky130_fd_sc_hd__decap_3
XFILLER_15_727 VGND VGND VPWR VPWR sky130_fd_sc_hd__fill_1
XFILLER_82_693 VGND VGND VPWR VPWR sky130_fd_sc_hd__decap_3
XFILLER_54_384 VGND VGND VPWR VPWR sky130_fd_sc_hd__decap_3
XFILLER_120_20 VGND VGND VPWR VPWR sky130_fd_sc_hd__decap_3
XFILLER_81_192 VGND VGND VPWR VPWR sky130_fd_sc_hd__decap_3
XFILLER_120_53 VGND VGND VPWR VPWR sky130_fd_sc_hd__decap_3
Xfanout30 _6370_/A VGND VGND VPWR VPWR _6504_/A sky130_fd_sc_hd__buf_1
XFILLER_30_719 VGND VGND VPWR VPWR sky130_fd_sc_hd__decap_3
Xfanout41 fanout46/X VGND VGND VPWR VPWR _6569_/A sky130_fd_sc_hd__buf_1
Xfanout52 _6350_/A VGND VGND VPWR VPWR _6366_/A sky130_fd_sc_hd__clkdlybuf4s25_1
Xfanout63 _6622_/A VGND VGND VPWR VPWR _6621_/A sky130_fd_sc_hd__buf_1
XFILLER_120_97 VGND VGND VPWR VPWR sky130_fd_sc_hd__decap_3
XTAP_TAPCELL_ROW_12_427 VGND VPWR sky130_fd_sc_hd__tapvpwrvgnd_1
Xfanout74 _6288_/A VGND VGND VPWR VPWR _6462_/A sky130_fd_sc_hd__buf_2
XFILLER_80_57 VGND VGND VPWR VPWR sky130_fd_sc_hd__decap_3
XFILLER_10_410 VGND VGND VPWR VPWR sky130_fd_sc_hd__decap_3
XFILLER_10_421 VGND VGND VPWR VPWR sky130_fd_sc_hd__decap_3
XFILLER_80_79 VGND VGND VPWR VPWR sky130_fd_sc_hd__decap_3
XFILLER_6_447 VGND VGND VPWR VPWR sky130_fd_sc_hd__decap_3
XFILLER_108_353 VGND VGND VPWR VPWR sky130_fd_sc_hd__decap_3
XFILLER_89_55 VGND VGND VPWR VPWR sky130_fd_sc_hd__fill_1
XTAP_TAPCELL_ROW_79_1292 VGND VPWR sky130_fd_sc_hd__tapvpwrvgnd_1
XFILLER_123_323 VGND VGND VPWR VPWR sky130_fd_sc_hd__decap_3
XFILLER_2_620 VGND VGND VPWR VPWR sky130_fd_sc_hd__decap_3
XFILLER_123_345 VGND VGND VPWR VPWR sky130_fd_sc_hd__decap_3
XFILLER_2_675 VGND VGND VPWR VPWR sky130_fd_sc_hd__decap_3
XFILLER_123_389 VGND VGND VPWR VPWR sky130_fd_sc_hd__decap_3
XFILLER_89_270 VGND VGND VPWR VPWR sky130_fd_sc_hd__decap_3
XFILLER_104_581 VGND VGND VPWR VPWR sky130_fd_sc_hd__decap_3
XFILLER_89_281 VGND VGND VPWR VPWR sky130_fd_sc_hd__decap_3
XFILLER_1_185 VGND VGND VPWR VPWR sky130_fd_sc_hd__decap_3
XFILLER_104_592 VGND VGND VPWR VPWR sky130_fd_sc_hd__decap_3
XFILLER_77_476 VGND VGND VPWR VPWR sky130_fd_sc_hd__decap_3
XFILLER_37_307 VGND VGND VPWR VPWR sky130_fd_sc_hd__decap_3
XFILLER_92_413 VGND VGND VPWR VPWR sky130_fd_sc_hd__decap_3
XFILLER_49_178 VGND VGND VPWR VPWR sky130_fd_sc_hd__decap_3
XFILLER_65_638 VGND VGND VPWR VPWR sky130_fd_sc_hd__decap_3
XFILLER_92_435 VGND VGND VPWR VPWR sky130_fd_sc_hd__decap_3
XFILLER_58_690 VGND VGND VPWR VPWR sky130_fd_sc_hd__decap_3
XFILLER_92_468 VGND VGND VPWR VPWR sky130_fd_sc_hd__decap_3
XFILLER_80_619 VGND VGND VPWR VPWR sky130_fd_sc_hd__decap_3
XFILLER_45_340 VGND VGND VPWR VPWR sky130_fd_sc_hd__decap_3
XFILLER_73_671 VGND VGND VPWR VPWR sky130_fd_sc_hd__fill_1
XFILLER_18_587 VGND VGND VPWR VPWR sky130_fd_sc_hd__fill_1
XFILLER_73_682 VGND VGND VPWR VPWR sky130_fd_sc_hd__decap_3
XFILLER_18_598 VGND VGND VPWR VPWR sky130_fd_sc_hd__decap_3
XFILLER_72_192 VGND VGND VPWR VPWR sky130_fd_sc_hd__decap_3
XFILLER_60_365 VGND VGND VPWR VPWR sky130_fd_sc_hd__decap_3
X_3730_ _6956_/Q _3889_/A2 _3917_/A2 _6950_/Q _3729_/X VGND VGND VPWR VPWR _3730_/X
+ sky130_fd_sc_hd__a221o_2
XFILLER_60_398 VGND VGND VPWR VPWR sky130_fd_sc_hd__decap_3
XFILLER_13_281 VGND VGND VPWR VPWR sky130_fd_sc_hd__decap_3
XFILLER_119_629 VGND VGND VPWR VPWR sky130_fd_sc_hd__decap_3
XFILLER_9_263 VGND VGND VPWR VPWR sky130_fd_sc_hd__decap_3
XFILLER_118_106 VGND VGND VPWR VPWR sky130_fd_sc_hd__decap_3
X_3661_ _3991_/B _3665_/B VGND VGND VPWR VPWR _3661_/X sky130_fd_sc_hd__and2_4
X_5400_ _5400_/A0 _5011_/X _5427_/S VGND VGND VPWR VPWR _7133_/D sky130_fd_sc_hd__mux2_2
Xclkload11 _7380_/CLK VGND VGND VPWR VPWR clkload11/Y sky130_fd_sc_hd__clkinv_2
Xclkload22 _6942_/CLK VGND VGND VPWR VPWR clkload22/X sky130_fd_sc_hd__clkbuf_8
X_6380_ _6608_/A VGND VGND VPWR VPWR _6380_/Y sky130_fd_sc_hd__inv_2
Xclkload33 _7406_/CLK VGND VGND VPWR VPWR clkload33/Y sky130_fd_sc_hd__clkinv_2
X_3592_ _4292_/B _3620_/C wire560/X VGND VGND VPWR VPWR _3592_/X sky130_fd_sc_hd__a21o_2
X_5331_ _5331_/A0 _5011_/X _5340_/S VGND VGND VPWR VPWR _7165_/D sky130_fd_sc_hd__mux2_2
XFILLER_114_323 VGND VGND VPWR VPWR sky130_fd_sc_hd__decap_3
XFILLER_5_491 VGND VGND VPWR VPWR sky130_fd_sc_hd__decap_3
XFILLER_114_345 VGND VGND VPWR VPWR sky130_fd_sc_hd__decap_3
X_5262_ _5262_/A0 _4978_/X _5278_/S VGND VGND VPWR VPWR _7199_/D sky130_fd_sc_hd__mux2_2
XFILLER_88_719 VGND VGND VPWR VPWR sky130_fd_sc_hd__decap_3
X_7001_ _7370_/CLK _7001_/D _6281_/Y VGND VGND VPWR VPWR _7001_/Q sky130_fd_sc_hd__dfrtp_2
X_4213_ _7292_/Q _4244_/B _4261_/A2 _7356_/Q _4248_/A VGND VGND VPWR VPWR _4213_/X
+ sky130_fd_sc_hd__a221o_2
XFILLER_68_421 VGND VGND VPWR VPWR sky130_fd_sc_hd__decap_3
X_4144_ _7362_/Q _4419_/B1 _4459_/C1 _7170_/Q VGND VGND VPWR VPWR _4144_/X sky130_fd_sc_hd__a22o_2
XFILLER_68_454 VGND VGND VPWR VPWR sky130_fd_sc_hd__decap_3
XFILLER_110_551 VGND VGND VPWR VPWR sky130_fd_sc_hd__decap_3
XFILLER_83_402 VGND VGND VPWR VPWR sky130_fd_sc_hd__decap_3
XFILLER_56_616 VGND VGND VPWR VPWR sky130_fd_sc_hd__decap_3
XFILLER_28_307 VGND VGND VPWR VPWR sky130_fd_sc_hd__fill_1
XFILLER_28_318 VGND VGND VPWR VPWR sky130_fd_sc_hd__decap_3
XFILLER_18_29 VGND VGND VPWR VPWR sky130_fd_sc_hd__decap_3
XFILLER_110_584 VGND VGND VPWR VPWR sky130_fd_sc_hd__decap_3
XFILLER_68_498 VGND VGND VPWR VPWR sky130_fd_sc_hd__decap_3
X_4075_ _7211_/Q _3935_/S _4837_/S _7307_/Q VGND VGND VPWR VPWR _4075_/X sky130_fd_sc_hd__a22o_2
XFILLER_110_595 VGND VGND VPWR VPWR sky130_fd_sc_hd__decap_3
XFILLER_83_479 VGND VGND VPWR VPWR sky130_fd_sc_hd__decap_3
XFILLER_64_660 VGND VGND VPWR VPWR sky130_fd_sc_hd__decap_3
XTAP_TAPCELL_ROW_104_1617 VGND VPWR sky130_fd_sc_hd__tapvpwrvgnd_1
XFILLER_24_513 VGND VGND VPWR VPWR sky130_fd_sc_hd__decap_3
XTAP_TAPCELL_ROW_47_880 VGND VPWR sky130_fd_sc_hd__tapvpwrvgnd_1
XFILLER_64_693 VGND VGND VPWR VPWR sky130_fd_sc_hd__decap_3
XFILLER_63_181 VGND VGND VPWR VPWR sky130_fd_sc_hd__decap_3
XFILLER_12_719 VGND VGND VPWR VPWR sky130_fd_sc_hd__decap_3
X_4977_ _4977_/A _4977_/B VGND VGND VPWR VPWR _6993_/D sky130_fd_sc_hd__nor2_2
X_6716_ _7371_/CLK _6716_/D VGND VGND VPWR VPWR _6716_/Q sky130_fd_sc_hd__dfxtp_2
XTAP_TAPCELL_ROW_63_1082 VGND VPWR sky130_fd_sc_hd__tapvpwrvgnd_1
X_3928_ hold977/X _3991_/A _3927_/X VGND VGND VPWR VPWR _7375_/D sky130_fd_sc_hd__o21a_2
Xclkload5 clkload5/A VGND VGND VPWR VPWR clkload5/Y sky130_fd_sc_hd__bufinv_16
X_6647_ _6653_/A VGND VGND VPWR VPWR _6647_/Y sky130_fd_sc_hd__inv_2
X_3859_ _6924_/Q _3926_/A2 _3926_/B1 _6788_/Q _3858_/X VGND VGND VPWR VPWR _3859_/X
+ sky130_fd_sc_hd__a221o_2
XFILLER_50_38 VGND VGND VPWR VPWR sky130_fd_sc_hd__decap_3
XFILLER_118_640 VGND VGND VPWR VPWR sky130_fd_sc_hd__decap_3
X_6578_ _6610_/A VGND VGND VPWR VPWR _6578_/Y sky130_fd_sc_hd__inv_2
XFILLER_118_651 VGND VGND VPWR VPWR sky130_fd_sc_hd__decap_3
XFILLER_118_684 VGND VGND VPWR VPWR sky130_fd_sc_hd__decap_3
XFILLER_117_161 VGND VGND VPWR VPWR sky130_fd_sc_hd__decap_3
XFILLER_3_428 VGND VGND VPWR VPWR sky130_fd_sc_hd__decap_3
XTAP_TAPCELL_ROW_115_1757 VGND VPWR sky130_fd_sc_hd__tapvpwrvgnd_1
XFILLER_105_323 VGND VGND VPWR VPWR sky130_fd_sc_hd__decap_3
XTAP_TAPCELL_ROW_115_1768 VGND VPWR sky130_fd_sc_hd__tapvpwrvgnd_1
XFILLER_117_194 VGND VGND VPWR VPWR sky130_fd_sc_hd__fill_2
XFILLER_105_367 VGND VGND VPWR VPWR sky130_fd_sc_hd__decap_3
XFILLER_78_218 VGND VGND VPWR VPWR sky130_fd_sc_hd__decap_3
XFILLER_105_389 VGND VGND VPWR VPWR sky130_fd_sc_hd__decap_3
XFILLER_115_31 VGND VGND VPWR VPWR sky130_fd_sc_hd__decap_3
XFILLER_86_251 VGND VGND VPWR VPWR sky130_fd_sc_hd__fill_1
XFILLER_19_307 VGND VGND VPWR VPWR sky130_fd_sc_hd__decap_3
XFILLER_86_262 VGND VGND VPWR VPWR sky130_fd_sc_hd__decap_3
XFILLER_75_24 VGND VGND VPWR VPWR sky130_fd_sc_hd__decap_3
XFILLER_59_476 VGND VGND VPWR VPWR sky130_fd_sc_hd__decap_3
XFILLER_115_75 VGND VGND VPWR VPWR sky130_fd_sc_hd__decap_3
XFILLER_101_573 VGND VGND VPWR VPWR sky130_fd_sc_hd__decap_3
XFILLER_47_638 VGND VGND VPWR VPWR sky130_fd_sc_hd__decap_3
XFILLER_19_329 VGND VGND VPWR VPWR sky130_fd_sc_hd__decap_3
XFILLER_75_57 VGND VGND VPWR VPWR sky130_fd_sc_hd__decap_3
XFILLER_46_126 VGND VGND VPWR VPWR sky130_fd_sc_hd__decap_3
XFILLER_46_137 VGND VGND VPWR VPWR sky130_fd_sc_hd__decap_3
XFILLER_74_457 VGND VGND VPWR VPWR sky130_fd_sc_hd__decap_3
XFILLER_62_608 VGND VGND VPWR VPWR sky130_fd_sc_hd__decap_3
XFILLER_27_340 VGND VGND VPWR VPWR sky130_fd_sc_hd__decap_3
XFILLER_61_107 VGND VGND VPWR VPWR sky130_fd_sc_hd__decap_3
XFILLER_55_671 VGND VGND VPWR VPWR sky130_fd_sc_hd__fill_1
XFILLER_15_502 VGND VGND VPWR VPWR sky130_fd_sc_hd__fill_2
XFILLER_55_682 VGND VGND VPWR VPWR sky130_fd_sc_hd__decap_3
XFILLER_27_373 VGND VGND VPWR VPWR sky130_fd_sc_hd__decap_3
XFILLER_15_535 VGND VGND VPWR VPWR sky130_fd_sc_hd__decap_3
XFILLER_54_181 VGND VGND VPWR VPWR sky130_fd_sc_hd__decap_3
XFILLER_70_663 VGND VGND VPWR VPWR sky130_fd_sc_hd__decap_3
XFILLER_15_579 VGND VGND VPWR VPWR sky130_fd_sc_hd__decap_3
XFILLER_30_505 VGND VGND VPWR VPWR sky130_fd_sc_hd__decap_3
XFILLER_70_696 VGND VGND VPWR VPWR sky130_fd_sc_hd__decap_3
XTAP_TAPCELL_ROW_25_596 VGND VPWR sky130_fd_sc_hd__tapvpwrvgnd_1
XFILLER_7_712 VGND VGND VPWR VPWR sky130_fd_sc_hd__decap_3
XFILLER_10_262 VGND VGND VPWR VPWR sky130_fd_sc_hd__decap_3
XFILLER_10_295 VGND VGND VPWR VPWR sky130_fd_sc_hd__decap_3
XFILLER_109_662 VGND VGND VPWR VPWR sky130_fd_sc_hd__decap_3
XFILLER_109_673 VGND VGND VPWR VPWR sky130_fd_sc_hd__decap_3
XFILLER_40_71 VGND VGND VPWR VPWR sky130_fd_sc_hd__fill_1
XFILLER_123_131 VGND VGND VPWR VPWR sky130_fd_sc_hd__decap_3
XFILLER_123_164 VGND VGND VPWR VPWR sky130_fd_sc_hd__decap_3
XFILLER_111_326 VGND VGND VPWR VPWR sky130_fd_sc_hd__decap_3
XFILLER_123_197 VGND VGND VPWR VPWR sky130_fd_sc_hd__decap_3
XFILLER_111_337 VGND VGND VPWR VPWR sky130_fd_sc_hd__decap_3
XFILLER_111_359 VGND VGND VPWR VPWR sky130_fd_sc_hd__decap_3
XFILLER_93_700 VGND VGND VPWR VPWR sky130_fd_sc_hd__decap_3
XFILLER_77_251 VGND VGND VPWR VPWR sky130_fd_sc_hd__fill_1
XFILLER_77_262 VGND VGND VPWR VPWR sky130_fd_sc_hd__decap_3
XFILLER_38_616 VGND VGND VPWR VPWR sky130_fd_sc_hd__decap_3
XFILLER_65_413 VGND VGND VPWR VPWR sky130_fd_sc_hd__decap_3
XFILLER_1_21 VGND VGND VPWR VPWR sky130_fd_sc_hd__decap_3
XFILLER_77_284 VGND VGND VPWR VPWR sky130_fd_sc_hd__decap_3
XFILLER_92_232 VGND VGND VPWR VPWR sky130_fd_sc_hd__decap_3
XFILLER_65_446 VGND VGND VPWR VPWR sky130_fd_sc_hd__fill_2
XFILLER_1_54 VGND VGND VPWR VPWR sky130_fd_sc_hd__fill_2
XFILLER_92_265 VGND VGND VPWR VPWR sky130_fd_sc_hd__decap_3
XFILLER_46_660 VGND VGND VPWR VPWR sky130_fd_sc_hd__decap_3
XFILLER_52_118 VGND VGND VPWR VPWR sky130_fd_sc_hd__fill_1
XFILLER_46_693 VGND VGND VPWR VPWR sky130_fd_sc_hd__decap_3
XFILLER_33_310 VGND VGND VPWR VPWR sky130_fd_sc_hd__decap_3
XFILLER_80_449 VGND VGND VPWR VPWR sky130_fd_sc_hd__decap_3
XFILLER_45_181 VGND VGND VPWR VPWR sky130_fd_sc_hd__decap_3
XFILLER_61_641 VGND VGND VPWR VPWR sky130_fd_sc_hd__decap_3
XFILLER_33_343 VGND VGND VPWR VPWR sky130_fd_sc_hd__decap_3
X_4831_ _4969_/B _4827_/X _4828_/X _4830_/X VGND VGND VPWR VPWR _5657_/A sky130_fd_sc_hd__a211o_2
XFILLER_61_685 VGND VGND VPWR VPWR sky130_fd_sc_hd__decap_3
XFILLER_21_538 VGND VGND VPWR VPWR sky130_fd_sc_hd__fill_1
X_4762_ _4762_/A _4762_/B VGND VGND VPWR VPWR _4762_/Y sky130_fd_sc_hd__nor2_2
XFILLER_60_195 VGND VGND VPWR VPWR sky130_fd_sc_hd__fill_1
X_6501_ _6566_/A VGND VGND VPWR VPWR _6501_/Y sky130_fd_sc_hd__inv_2
X_3713_ _3733_/C VGND VGND VPWR VPWR _3746_/C sky130_fd_sc_hd__inv_4
X_4693_ _7007_/Q _4750_/B VGND VGND VPWR VPWR _4728_/A sky130_fd_sc_hd__nand2_2
X_6432_ _6632_/A VGND VGND VPWR VPWR _6432_/Y sky130_fd_sc_hd__inv_2
X_3644_ _3629_/Y _3642_/X _3860_/S VGND VGND VPWR VPWR _4664_/B sky130_fd_sc_hd__o21a_2
X_6363_ _6363_/A VGND VGND VPWR VPWR _6363_/Y sky130_fd_sc_hd__inv_2
X_3575_ _7156_/Q _3366_/X _5229_/C _7124_/Q _3574_/X VGND VGND VPWR VPWR _3575_/X
+ sky130_fd_sc_hd__a221o_2
XFILLER_115_632 VGND VGND VPWR VPWR sky130_fd_sc_hd__decap_3
XFILLER_115_665 VGND VGND VPWR VPWR sky130_fd_sc_hd__decap_3
X_6294_ _6570_/A VGND VGND VPWR VPWR _6294_/Y sky130_fd_sc_hd__inv_2
XFILLER_115_676 VGND VGND VPWR VPWR sky130_fd_sc_hd__decap_3
XFILLER_114_164 VGND VGND VPWR VPWR sky130_fd_sc_hd__decap_3
XFILLER_102_304 VGND VGND VPWR VPWR sky130_fd_sc_hd__fill_1
X_5245_ _5245_/A0 _4836_/X _5258_/S VGND VGND VPWR VPWR _7207_/D sky130_fd_sc_hd__mux2_2
XFILLER_114_197 VGND VGND VPWR VPWR sky130_fd_sc_hd__decap_3
XFILLER_102_348 VGND VGND VPWR VPWR sky130_fd_sc_hd__fill_2
XFILLER_96_560 VGND VGND VPWR VPWR sky130_fd_sc_hd__decap_3
XFILLER_56_402 VGND VGND VPWR VPWR sky130_fd_sc_hd__decap_3
XTAP_TAPCELL_ROW_110_1698 VGND VPWR sky130_fd_sc_hd__tapvpwrvgnd_1
XFILLER_68_262 VGND VGND VPWR VPWR sky130_fd_sc_hd__decap_3
XFILLER_84_722 VGND VGND VPWR VPWR sky130_fd_sc_hd__decap_3
XFILLER_29_638 VGND VGND VPWR VPWR sky130_fd_sc_hd__decap_3
XFILLER_83_210 VGND VGND VPWR VPWR sky130_fd_sc_hd__decap_3
XFILLER_56_424 VGND VGND VPWR VPWR sky130_fd_sc_hd__decap_3
XFILLER_28_115 VGND VGND VPWR VPWR sky130_fd_sc_hd__decap_3
XFILLER_68_295 VGND VGND VPWR VPWR sky130_fd_sc_hd__fill_1
XFILLER_56_457 VGND VGND VPWR VPWR sky130_fd_sc_hd__decap_3
XFILLER_83_243 VGND VGND VPWR VPWR sky130_fd_sc_hd__decap_3
XFILLER_28_159 VGND VGND VPWR VPWR sky130_fd_sc_hd__decap_3
X_4058_ _7244_/Q _4430_/A2 _4430_/B1 _7180_/Q _4057_/X VGND VGND VPWR VPWR _4058_/X
+ sky130_fd_sc_hd__a221o_2
XFILLER_83_276 VGND VGND VPWR VPWR sky130_fd_sc_hd__decap_3
XFILLER_37_671 VGND VGND VPWR VPWR sky130_fd_sc_hd__fill_1
XFILLER_83_287 VGND VGND VPWR VPWR sky130_fd_sc_hd__decap_3
XFILLER_37_682 VGND VGND VPWR VPWR sky130_fd_sc_hd__decap_3
XTAP_TAPCELL_ROW_65_1111 VGND VPWR sky130_fd_sc_hd__tapvpwrvgnd_1
XFILLER_36_170 VGND VGND VPWR VPWR sky130_fd_sc_hd__decap_3
XTAP_TAPCELL_ROW_42_809 VGND VPWR sky130_fd_sc_hd__tapvpwrvgnd_1
XFILLER_52_663 VGND VGND VPWR VPWR sky130_fd_sc_hd__decap_3
XFILLER_24_354 VGND VGND VPWR VPWR sky130_fd_sc_hd__decap_3
XFILLER_24_365 VGND VGND VPWR VPWR sky130_fd_sc_hd__decap_3
XFILLER_52_696 VGND VGND VPWR VPWR sky130_fd_sc_hd__decap_3
XFILLER_101_88 VGND VGND VPWR VPWR sky130_fd_sc_hd__decap_3
XTAP_TAPCELL_ROW_22_555 VGND VPWR sky130_fd_sc_hd__tapvpwrvgnd_1
XFILLER_20_560 VGND VGND VPWR VPWR sky130_fd_sc_hd__decap_3
XFILLER_4_704 VGND VGND VPWR VPWR sky130_fd_sc_hd__decap_3
XFILLER_106_610 VGND VGND VPWR VPWR sky130_fd_sc_hd__decap_3
XFILLER_118_470 VGND VGND VPWR VPWR sky130_fd_sc_hd__decap_3
XFILLER_3_225 VGND VGND VPWR VPWR sky130_fd_sc_hd__decap_3
XFILLER_118_492 VGND VGND VPWR VPWR sky130_fd_sc_hd__decap_3
XTAP_TAPCELL_ROW_76_1251 VGND VPWR sky130_fd_sc_hd__tapvpwrvgnd_1
XFILLER_106_643 VGND VGND VPWR VPWR sky130_fd_sc_hd__fill_1
XFILLER_10_41 VGND VGND VPWR VPWR sky130_fd_sc_hd__decap_3
XFILLER_106_654 VGND VGND VPWR VPWR sky130_fd_sc_hd__decap_3
XFILLER_105_131 VGND VGND VPWR VPWR sky130_fd_sc_hd__decap_3
XFILLER_79_505 VGND VGND VPWR VPWR sky130_fd_sc_hd__fill_2
XFILLER_106_687 VGND VGND VPWR VPWR sky130_fd_sc_hd__decap_3
XFILLER_10_85 VGND VGND VPWR VPWR sky130_fd_sc_hd__decap_3
XFILLER_10_96 VGND VGND VPWR VPWR sky130_fd_sc_hd__fill_1
XFILLER_86_12 VGND VGND VPWR VPWR sky130_fd_sc_hd__decap_3
XFILLER_79_549 VGND VGND VPWR VPWR sky130_fd_sc_hd__decap_3
XFILLER_121_635 VGND VGND VPWR VPWR sky130_fd_sc_hd__decap_3
XFILLER_105_186 VGND VGND VPWR VPWR sky130_fd_sc_hd__decap_3
XFILLER_121_668 VGND VGND VPWR VPWR sky130_fd_sc_hd__decap_3
XFILLER_121_679 VGND VGND VPWR VPWR sky130_fd_sc_hd__decap_3
XFILLER_75_700 VGND VGND VPWR VPWR sky130_fd_sc_hd__decap_3
XFILLER_86_67 VGND VGND VPWR VPWR sky130_fd_sc_hd__fill_1
XFILLER_120_167 VGND VGND VPWR VPWR sky130_fd_sc_hd__decap_3
XFILLER_47_402 VGND VGND VPWR VPWR sky130_fd_sc_hd__decap_3
XFILLER_87_582 VGND VGND VPWR VPWR sky130_fd_sc_hd__decap_3
XFILLER_74_221 VGND VGND VPWR VPWR sky130_fd_sc_hd__decap_3
XFILLER_47_479 VGND VGND VPWR VPWR sky130_fd_sc_hd__decap_3
XFILLER_74_265 VGND VGND VPWR VPWR sky130_fd_sc_hd__decap_3
XFILLER_28_660 VGND VGND VPWR VPWR sky130_fd_sc_hd__decap_3
XFILLER_90_725 VGND VGND VPWR VPWR sky130_fd_sc_hd__decap_3
XFILLER_74_287 VGND VGND VPWR VPWR sky130_fd_sc_hd__decap_3
XFILLER_62_427 VGND VGND VPWR VPWR sky130_fd_sc_hd__decap_3
XFILLER_34_118 VGND VGND VPWR VPWR sky130_fd_sc_hd__decap_3
XFILLER_28_693 VGND VGND VPWR VPWR sky130_fd_sc_hd__decap_3
XTAP_TAPCELL_ROW_2_291 VGND VPWR sky130_fd_sc_hd__tapvpwrvgnd_1
XFILLER_15_321 VGND VGND VPWR VPWR sky130_fd_sc_hd__decap_3
XFILLER_43_641 VGND VGND VPWR VPWR sky130_fd_sc_hd__decap_3
XFILLER_15_343 VGND VGND VPWR VPWR sky130_fd_sc_hd__decap_3
XFILLER_42_151 VGND VGND VPWR VPWR sky130_fd_sc_hd__decap_3
XFILLER_43_685 VGND VGND VPWR VPWR sky130_fd_sc_hd__decap_3
XFILLER_42_173 VGND VGND VPWR VPWR sky130_fd_sc_hd__decap_3
XFILLER_30_346 VGND VGND VPWR VPWR sky130_fd_sc_hd__decap_3
XFILLER_30_368 VGND VGND VPWR VPWR sky130_fd_sc_hd__decap_3
XFILLER_11_582 VGND VGND VPWR VPWR sky130_fd_sc_hd__decap_3
XFILLER_7_542 VGND VGND VPWR VPWR sky130_fd_sc_hd__decap_3
XFILLER_7_564 VGND VGND VPWR VPWR sky130_fd_sc_hd__decap_3
XFILLER_116_407 VGND VGND VPWR VPWR sky130_fd_sc_hd__decap_3
XFILLER_7_597 VGND VGND VPWR VPWR sky130_fd_sc_hd__decap_3
X_3360_ _6980_/Q _5129_/B _3371_/A VGND VGND VPWR VPWR _3386_/B sky130_fd_sc_hd__mux2_2
XFILLER_112_613 VGND VGND VPWR VPWR sky130_fd_sc_hd__decap_3
XFILLER_97_346 VGND VGND VPWR VPWR sky130_fd_sc_hd__decap_3
XFILLER_112_657 VGND VGND VPWR VPWR sky130_fd_sc_hd__decap_3
X_5030_ _6989_/Q _5044_/A VGND VGND VPWR VPWR _6989_/D sky130_fd_sc_hd__xor2_2
XFILLER_85_508 VGND VGND VPWR VPWR sky130_fd_sc_hd__decap_3
Xhold1209 _7216_/Q VGND VGND VPWR VPWR _5225_/A sky130_fd_sc_hd__dlygate4sd3_1
XFILLER_78_560 VGND VGND VPWR VPWR sky130_fd_sc_hd__decap_3
XFILLER_111_167 VGND VGND VPWR VPWR sky130_fd_sc_hd__fill_1
XFILLER_38_402 VGND VGND VPWR VPWR sky130_fd_sc_hd__decap_3
XFILLER_78_582 VGND VGND VPWR VPWR sky130_fd_sc_hd__decap_3
XFILLER_66_722 VGND VGND VPWR VPWR sky130_fd_sc_hd__decap_3
XFILLER_111_178 VGND VGND VPWR VPWR sky130_fd_sc_hd__decap_3
XFILLER_65_210 VGND VGND VPWR VPWR sky130_fd_sc_hd__decap_3
XFILLER_120_690 VGND VGND VPWR VPWR sky130_fd_sc_hd__decap_3
XFILLER_38_446 VGND VGND VPWR VPWR sky130_fd_sc_hd__decap_3
XFILLER_81_703 VGND VGND VPWR VPWR sky130_fd_sc_hd__decap_3
XFILLER_26_619 VGND VGND VPWR VPWR sky130_fd_sc_hd__decap_3
X_6981_ clkload6/A _6981_/D _6261_/Y VGND VGND VPWR VPWR _6981_/Q sky130_fd_sc_hd__dfrtp_2
XFILLER_93_585 VGND VGND VPWR VPWR sky130_fd_sc_hd__decap_3
XFILLER_65_276 VGND VGND VPWR VPWR sky130_fd_sc_hd__decap_3
XFILLER_19_671 VGND VGND VPWR VPWR sky130_fd_sc_hd__fill_1
XFILLER_65_287 VGND VGND VPWR VPWR sky130_fd_sc_hd__decap_3
XFILLER_19_682 VGND VGND VPWR VPWR sky130_fd_sc_hd__decap_3
XFILLER_53_449 VGND VGND VPWR VPWR sky130_fd_sc_hd__decap_3
XFILLER_80_246 VGND VGND VPWR VPWR sky130_fd_sc_hd__decap_3
XFILLER_18_192 VGND VGND VPWR VPWR sky130_fd_sc_hd__decap_3
XFILLER_80_268 VGND VGND VPWR VPWR sky130_fd_sc_hd__decap_3
XFILLER_34_663 VGND VGND VPWR VPWR sky130_fd_sc_hd__decap_3
XFILLER_21_302 VGND VGND VPWR VPWR sky130_fd_sc_hd__fill_1
XFILLER_34_696 VGND VGND VPWR VPWR sky130_fd_sc_hd__decap_3
X_4814_ _4814_/A _4814_/B VGND VGND VPWR VPWR _4814_/Y sky130_fd_sc_hd__nor2_2
XFILLER_33_184 VGND VGND VPWR VPWR sky130_fd_sc_hd__fill_1
XFILLER_21_324 VGND VGND VPWR VPWR sky130_fd_sc_hd__decap_3
XTAP_TAPCELL_ROW_60_1041 VGND VPWR sky130_fd_sc_hd__tapvpwrvgnd_1
XFILLER_21_368 VGND VGND VPWR VPWR sky130_fd_sc_hd__decap_3
XTAP_TAPCELL_ROW_60_1052 VGND VPWR sky130_fd_sc_hd__tapvpwrvgnd_1
X_4745_ _4745_/A VGND VGND VPWR VPWR _4745_/Y sky130_fd_sc_hd__inv_2
XFILLER_21_379 VGND VGND VPWR VPWR sky130_fd_sc_hd__decap_3
X_4676_ _5648_/A _5067_/B _6985_/Q _6986_/Q _6987_/Q VGND VGND VPWR VPWR _5045_/B
+ sky130_fd_sc_hd__o2111a_2
X_6415_ _6643_/A VGND VGND VPWR VPWR _6415_/Y sky130_fd_sc_hd__inv_2
X_3627_ _3746_/A _3746_/B _3733_/C VGND VGND VPWR VPWR _5660_/A sky130_fd_sc_hd__and3_2
X_7395_ _7395_/CLK _7395_/D _6675_/Y VGND VGND VPWR VPWR _7395_/Q sky130_fd_sc_hd__dfrtp_2
X_6346_ _6672_/A VGND VGND VPWR VPWR _6346_/Y sky130_fd_sc_hd__inv_2
X_3558_ _7061_/Q _3558_/B VGND VGND VPWR VPWR _3558_/X sky130_fd_sc_hd__or2_2
XTAP_TAPCELL_ROW_112_1727 VGND VPWR sky130_fd_sc_hd__tapvpwrvgnd_1
XFILLER_88_302 VGND VGND VPWR VPWR sky130_fd_sc_hd__decap_3
XFILLER_0_206 VGND VGND VPWR VPWR sky130_fd_sc_hd__decap_3
XFILLER_1_729 VGND VGND VPWR VPWR sky130_fd_sc_hd__decap_3
XFILLER_0_228 VGND VGND VPWR VPWR sky130_fd_sc_hd__decap_3
XFILLER_103_635 VGND VGND VPWR VPWR sky130_fd_sc_hd__decap_3
X_6277_ _6278_/A VGND VGND VPWR VPWR _6277_/Y sky130_fd_sc_hd__inv_2
XFILLER_88_335 VGND VGND VPWR VPWR sky130_fd_sc_hd__decap_3
XFILLER_102_112 VGND VGND VPWR VPWR sky130_fd_sc_hd__decap_3
X_3489_ _7311_/Q _3996_/S _3380_/Y _7343_/Q _3488_/X VGND VGND VPWR VPWR _3489_/X
+ sky130_fd_sc_hd__a221o_2
XFILLER_102_123 VGND VGND VPWR VPWR sky130_fd_sc_hd__decap_3
XFILLER_88_368 VGND VGND VPWR VPWR sky130_fd_sc_hd__decap_3
XFILLER_103_668 VGND VGND VPWR VPWR sky130_fd_sc_hd__decap_3
X_5228_ _5238_/B VGND VGND VPWR VPWR _5229_/B sky130_fd_sc_hd__inv_2
XFILLER_103_679 VGND VGND VPWR VPWR sky130_fd_sc_hd__decap_3
XFILLER_57_700 VGND VGND VPWR VPWR sky130_fd_sc_hd__decap_3
XTAP_TAPCELL_ROW_71_1192 VGND VPWR sky130_fd_sc_hd__tapvpwrvgnd_1
X_5159_ _5159_/A0 _4470_/X _5159_/S VGND VGND VPWR VPWR _7247_/D sky130_fd_sc_hd__mux2_2
XFILLER_96_390 VGND VGND VPWR VPWR sky130_fd_sc_hd__fill_1
XFILLER_56_232 VGND VGND VPWR VPWR sky130_fd_sc_hd__decap_3
XFILLER_72_725 VGND VGND VPWR VPWR sky130_fd_sc_hd__decap_3
XTAP_TAPCELL_ROW_27_614 VGND VPWR sky130_fd_sc_hd__tapvpwrvgnd_1
XFILLER_44_427 VGND VGND VPWR VPWR sky130_fd_sc_hd__decap_3
XFILLER_71_213 VGND VGND VPWR VPWR sky130_fd_sc_hd__decap_3
XFILLER_112_32 VGND VGND VPWR VPWR sky130_fd_sc_hd__decap_3
XFILLER_56_298 VGND VGND VPWR VPWR sky130_fd_sc_hd__fill_2
Xclkbuf_leaf_36_clk clkbuf_leaf_2_clk/A VGND VGND VPWR VPWR _7279_/CLK sky130_fd_sc_hd__clkbuf_16
XFILLER_71_246 VGND VGND VPWR VPWR sky130_fd_sc_hd__decap_3
XFILLER_72_14 VGND VGND VPWR VPWR sky130_fd_sc_hd__decap_3
XFILLER_25_641 VGND VGND VPWR VPWR sky130_fd_sc_hd__decap_3
XFILLER_112_65 VGND VGND VPWR VPWR sky130_fd_sc_hd__decap_3
XTAP_TAPCELL_ROW_55_978 VGND VPWR sky130_fd_sc_hd__tapvpwrvgnd_1
XFILLER_71_268 VGND VGND VPWR VPWR sky130_fd_sc_hd__decap_3
XTAP_TAPCELL_ROW_123_1867 VGND VPWR sky130_fd_sc_hd__tapvpwrvgnd_1
XFILLER_112_98 VGND VGND VPWR VPWR sky130_fd_sc_hd__decap_3
XTAP_TAPCELL_ROW_123_1878 VGND VPWR sky130_fd_sc_hd__tapvpwrvgnd_1
XFILLER_25_685 VGND VGND VPWR VPWR sky130_fd_sc_hd__decap_3
XFILLER_40_622 VGND VGND VPWR VPWR sky130_fd_sc_hd__decap_3
XFILLER_52_493 VGND VGND VPWR VPWR sky130_fd_sc_hd__decap_3
XFILLER_24_195 VGND VGND VPWR VPWR sky130_fd_sc_hd__fill_1
XFILLER_12_346 VGND VGND VPWR VPWR sky130_fd_sc_hd__decap_3
XFILLER_40_666 VGND VGND VPWR VPWR sky130_fd_sc_hd__decap_3
XFILLER_40_699 VGND VGND VPWR VPWR sky130_fd_sc_hd__fill_1
XFILLER_8_339 VGND VGND VPWR VPWR sky130_fd_sc_hd__decap_3
XFILLER_21_51 VGND VGND VPWR VPWR sky130_fd_sc_hd__decap_3
XFILLER_4_545 VGND VGND VPWR VPWR sky130_fd_sc_hd__decap_3
XFILLER_4_578 VGND VGND VPWR VPWR sky130_fd_sc_hd__decap_3
XFILLER_4_589 VGND VGND VPWR VPWR sky130_fd_sc_hd__decap_3
XFILLER_79_324 VGND VGND VPWR VPWR sky130_fd_sc_hd__fill_1
XFILLER_97_88 VGND VGND VPWR VPWR sky130_fd_sc_hd__fill_1
XFILLER_97_99 VGND VGND VPWR VPWR sky130_fd_sc_hd__decap_3
XTAP_TAPCELL_ROW_7_361 VGND VPWR sky130_fd_sc_hd__tapvpwrvgnd_1
XFILLER_67_508 VGND VGND VPWR VPWR sky130_fd_sc_hd__decap_3
XFILLER_121_476 VGND VGND VPWR VPWR sky130_fd_sc_hd__decap_3
XFILLER_48_722 VGND VGND VPWR VPWR sky130_fd_sc_hd__decap_3
XTAP_TAPCELL_ROW_89_1420 VGND VPWR sky130_fd_sc_hd__tapvpwrvgnd_1
XFILLER_102_690 VGND VGND VPWR VPWR sky130_fd_sc_hd__decap_3
XFILLER_47_232 VGND VGND VPWR VPWR sky130_fd_sc_hd__decap_3
XFILLER_63_703 VGND VGND VPWR VPWR sky130_fd_sc_hd__decap_3
XFILLER_47_265 VGND VGND VPWR VPWR sky130_fd_sc_hd__fill_1
XFILLER_47_276 VGND VGND VPWR VPWR sky130_fd_sc_hd__decap_3
XFILLER_90_533 VGND VGND VPWR VPWR sky130_fd_sc_hd__fill_2
Xclkbuf_leaf_27_clk clkbuf_3_6__f_clk/X VGND VGND VPWR VPWR _7362_/CLK sky130_fd_sc_hd__clkbuf_16
XFILLER_62_235 VGND VGND VPWR VPWR sky130_fd_sc_hd__decap_3
XFILLER_90_566 VGND VGND VPWR VPWR sky130_fd_sc_hd__decap_3
XFILLER_50_408 VGND VGND VPWR VPWR sky130_fd_sc_hd__decap_3
XFILLER_16_663 VGND VGND VPWR VPWR sky130_fd_sc_hd__decap_3
XFILLER_31_600 VGND VGND VPWR VPWR sky130_fd_sc_hd__decap_3
XFILLER_15_151 VGND VGND VPWR VPWR sky130_fd_sc_hd__fill_1
XFILLER_16_696 VGND VGND VPWR VPWR sky130_fd_sc_hd__decap_3
XFILLER_94_6 VGND VGND VPWR VPWR sky130_fd_sc_hd__decap_3
XFILLER_15_184 VGND VGND VPWR VPWR sky130_fd_sc_hd__decap_3
XFILLER_70_290 VGND VGND VPWR VPWR sky130_fd_sc_hd__decap_3
XFILLER_31_644 VGND VGND VPWR VPWR sky130_fd_sc_hd__decap_3
XFILLER_15_195 VGND VGND VPWR VPWR sky130_fd_sc_hd__decap_3
XFILLER_30_132 VGND VGND VPWR VPWR sky130_fd_sc_hd__decap_3
XFILLER_62_91 VGND VGND VPWR VPWR sky130_fd_sc_hd__fill_2
XFILLER_30_154 VGND VGND VPWR VPWR sky130_fd_sc_hd__decap_3
XFILLER_31_688 VGND VGND VPWR VPWR sky130_fd_sc_hd__decap_3
XFILLER_30_187 VGND VGND VPWR VPWR sky130_fd_sc_hd__decap_3
X_4530_ _4530_/A0 _7282_/Q _4532_/S VGND VGND VPWR VPWR _7314_/D sky130_fd_sc_hd__mux2_2
XFILLER_117_727 VGND VGND VPWR VPWR sky130_fd_sc_hd__fill_1
X_3412_ _7187_/Q _4471_/S _4354_/B1 _7379_/Q VGND VGND VPWR VPWR _3412_/X sky130_fd_sc_hd__a22o_2
X_7180_ _7372_/CLK _7180_/D _6460_/Y VGND VGND VPWR VPWR _7180_/Q sky130_fd_sc_hd__dfrtp_2
X_4392_ _7369_/Q _4394_/B _4434_/B1 _7145_/Q _4391_/X VGND VGND VPWR VPWR _4392_/X
+ sky130_fd_sc_hd__a221o_2
XFILLER_98_622 VGND VGND VPWR VPWR sky130_fd_sc_hd__decap_3
XFILLER_112_421 VGND VGND VPWR VPWR sky130_fd_sc_hd__decap_3
XFILLER_98_666 VGND VGND VPWR VPWR sky130_fd_sc_hd__decap_3
XFILLER_112_454 VGND VGND VPWR VPWR sky130_fd_sc_hd__decap_3
XFILLER_85_305 VGND VGND VPWR VPWR sky130_fd_sc_hd__decap_3
XFILLER_39_700 VGND VGND VPWR VPWR sky130_fd_sc_hd__decap_3
XFILLER_100_616 VGND VGND VPWR VPWR sky130_fd_sc_hd__decap_3
Xhold1006 _7194_/Q VGND VGND VPWR VPWR _5272_/A0 sky130_fd_sc_hd__dlygate4sd3_1
XFILLER_98_699 VGND VGND VPWR VPWR sky130_fd_sc_hd__fill_1
Xhold1017 _7184_/Q VGND VGND VPWR VPWR _5290_/A0 sky130_fd_sc_hd__dlygate4sd3_1
Xhold1028 _7260_/Q VGND VGND VPWR VPWR _5028_/A0 sky130_fd_sc_hd__dlygate4sd3_1
Xhold1039 _7275_/Q VGND VGND VPWR VPWR _4772_/A0 sky130_fd_sc_hd__dlygate4sd3_1
XFILLER_78_390 VGND VGND VPWR VPWR sky130_fd_sc_hd__decap_3
XFILLER_66_530 VGND VGND VPWR VPWR sky130_fd_sc_hd__fill_2
XFILLER_38_221 VGND VGND VPWR VPWR sky130_fd_sc_hd__decap_3
XFILLER_38_265 VGND VGND VPWR VPWR sky130_fd_sc_hd__decap_3
XFILLER_54_725 VGND VGND VPWR VPWR sky130_fd_sc_hd__decap_3
XFILLER_53_202 VGND VGND VPWR VPWR sky130_fd_sc_hd__decap_3
XFILLER_38_298 VGND VGND VPWR VPWR sky130_fd_sc_hd__decap_3
XPHY_EDGE_ROW_5_Right_5 VGND VGND VPWR VPWR sky130_fd_sc_hd__decap_3
XFILLER_93_393 VGND VGND VPWR VPWR sky130_fd_sc_hd__fill_2
X_6964_ _6978_/CLK _6964_/D VGND VGND VPWR VPWR _6964_/Q sky130_fd_sc_hd__dfxtp_2
Xclkbuf_leaf_18_clk clkload2/A VGND VGND VPWR VPWR _7404_/CLK sky130_fd_sc_hd__clkbuf_16
XFILLER_53_246 VGND VGND VPWR VPWR sky130_fd_sc_hd__decap_3
XFILLER_81_588 VGND VGND VPWR VPWR sky130_fd_sc_hd__decap_3
XFILLER_53_279 VGND VGND VPWR VPWR sky130_fd_sc_hd__fill_1
XFILLER_34_460 VGND VGND VPWR VPWR sky130_fd_sc_hd__decap_3
X_6895_ _7371_/CLK _6895_/D VGND VGND VPWR VPWR _6895_/Q sky130_fd_sc_hd__dfxtp_2
XTAP_TAPCELL_ROW_52_937 VGND VPWR sky130_fd_sc_hd__tapvpwrvgnd_1
XTAP_TAPCELL_ROW_52_948 VGND VPWR sky130_fd_sc_hd__tapvpwrvgnd_1
XFILLER_22_622 VGND VGND VPWR VPWR sky130_fd_sc_hd__decap_3
XFILLER_61_290 VGND VGND VPWR VPWR sky130_fd_sc_hd__decap_3
XFILLER_22_666 VGND VGND VPWR VPWR sky130_fd_sc_hd__decap_3
XFILLER_22_699 VGND VGND VPWR VPWR sky130_fd_sc_hd__fill_1
XTAP_TAPCELL_ROW_32_683 VGND VPWR sky130_fd_sc_hd__tapvpwrvgnd_1
XFILLER_21_187 VGND VGND VPWR VPWR sky130_fd_sc_hd__fill_1
X_4728_ _4728_/A _4728_/B VGND VGND VPWR VPWR _4729_/B sky130_fd_sc_hd__nand2_2
XFILLER_108_716 VGND VGND VPWR VPWR sky130_fd_sc_hd__decap_3
X_4659_ _4814_/A _4457_/X _4658_/Y _4852_/A _4040_/Y VGND VGND VPWR VPWR _4659_/X
+ sky130_fd_sc_hd__o2111a_2
XFILLER_107_237 VGND VGND VPWR VPWR sky130_fd_sc_hd__decap_3
XTAP_TAPCELL_ROW_73_1210 VGND VPWR sky130_fd_sc_hd__tapvpwrvgnd_1
Xhold840 _6942_/Q VGND VGND VPWR VPWR _6942_/D sky130_fd_sc_hd__dlygate4sd3_1
X_7378_ _7378_/CLK _7378_/D _6658_/Y VGND VGND VPWR VPWR _7378_/Q sky130_fd_sc_hd__dfrtp_2
XFILLER_89_600 VGND VGND VPWR VPWR sky130_fd_sc_hd__decap_3
Xhold851 _7073_/Q VGND VGND VPWR VPWR _7073_/D sky130_fd_sc_hd__dlygate4sd3_1
XFILLER_107_10 VGND VGND VPWR VPWR sky130_fd_sc_hd__decap_3
XTAP_TAPCELL_ROW_73_1221 VGND VPWR sky130_fd_sc_hd__tapvpwrvgnd_1
Xmax_cap570 _6581_/A VGND VGND VPWR VPWR _6387_/A sky130_fd_sc_hd__clkbuf_2
Xhold862 _7065_/Q VGND VGND VPWR VPWR _7065_/D sky130_fd_sc_hd__dlygate4sd3_1
Xhold873 _7109_/Q VGND VGND VPWR VPWR _7109_/D sky130_fd_sc_hd__dlygate4sd3_1
XFILLER_1_526 VGND VGND VPWR VPWR sky130_fd_sc_hd__decap_3
X_6329_ _6680_/A VGND VGND VPWR VPWR _6329_/Y sky130_fd_sc_hd__inv_2
Xhold884 _7075_/Q VGND VGND VPWR VPWR _7075_/D sky130_fd_sc_hd__dlygate4sd3_1
XFILLER_107_43 VGND VGND VPWR VPWR sky130_fd_sc_hd__decap_3
XFILLER_89_644 VGND VGND VPWR VPWR sky130_fd_sc_hd__decap_3
XFILLER_88_121 VGND VGND VPWR VPWR sky130_fd_sc_hd__fill_1
Xhold895 _7071_/Q VGND VGND VPWR VPWR _7071_/D sky130_fd_sc_hd__dlygate4sd3_1
XFILLER_1_559 VGND VGND VPWR VPWR sky130_fd_sc_hd__fill_1
XFILLER_49_508 VGND VGND VPWR VPWR sky130_fd_sc_hd__decap_3
XFILLER_67_36 VGND VGND VPWR VPWR sky130_fd_sc_hd__decap_3
XFILLER_89_688 VGND VGND VPWR VPWR sky130_fd_sc_hd__decap_3
XFILLER_88_165 VGND VGND VPWR VPWR sky130_fd_sc_hd__decap_3
XFILLER_107_98 VGND VGND VPWR VPWR sky130_fd_sc_hd__decap_3
XFILLER_88_176 VGND VGND VPWR VPWR sky130_fd_sc_hd__decap_3
XFILLER_103_487 VGND VGND VPWR VPWR sky130_fd_sc_hd__fill_1
XTAP_TAPCELL_ROW_4_320 VGND VPWR sky130_fd_sc_hd__tapvpwrvgnd_1
XFILLER_69_390 VGND VGND VPWR VPWR sky130_fd_sc_hd__fill_2
XFILLER_57_541 VGND VGND VPWR VPWR sky130_fd_sc_hd__decap_3
XFILLER_45_703 VGND VGND VPWR VPWR sky130_fd_sc_hd__decap_3
XFILLER_123_53 VGND VGND VPWR VPWR sky130_fd_sc_hd__decap_3
XFILLER_84_382 VGND VGND VPWR VPWR sky130_fd_sc_hd__decap_3
XFILLER_44_213 VGND VGND VPWR VPWR sky130_fd_sc_hd__decap_3
XFILLER_29_287 VGND VGND VPWR VPWR sky130_fd_sc_hd__decap_3
XPHY_EDGE_ROW_103_Left_227 VGND VGND VPWR VPWR sky130_fd_sc_hd__decap_3
XFILLER_83_57 VGND VGND VPWR VPWR sky130_fd_sc_hd__decap_3
XFILLER_44_246 VGND VGND VPWR VPWR sky130_fd_sc_hd__decap_3
XFILLER_60_728 VGND VGND VPWR VPWR sky130_fd_sc_hd__decap_3
XFILLER_13_600 VGND VGND VPWR VPWR sky130_fd_sc_hd__decap_3
XTAP_TAPCELL_ROW_84_1361 VGND VPWR sky130_fd_sc_hd__tapvpwrvgnd_1
XFILLER_13_644 VGND VGND VPWR VPWR sky130_fd_sc_hd__decap_3
XFILLER_9_615 VGND VGND VPWR VPWR sky130_fd_sc_hd__fill_1
XFILLER_9_626 VGND VGND VPWR VPWR sky130_fd_sc_hd__decap_3
XFILLER_13_688 VGND VGND VPWR VPWR sky130_fd_sc_hd__decap_3
XFILLER_40_474 VGND VGND VPWR VPWR sky130_fd_sc_hd__fill_2
XFILLER_12_165 VGND VGND VPWR VPWR sky130_fd_sc_hd__decap_3
XFILLER_9_659 VGND VGND VPWR VPWR sky130_fd_sc_hd__decap_3
XFILLER_8_169 VGND VGND VPWR VPWR sky130_fd_sc_hd__decap_3
XPHY_EDGE_ROW_112_Left_236 VGND VGND VPWR VPWR sky130_fd_sc_hd__decap_3
XTAP_TAPCELL_ROW_10_399 VGND VPWR sky130_fd_sc_hd__tapvpwrvgnd_1
XFILLER_114_719 VGND VGND VPWR VPWR sky130_fd_sc_hd__decap_3
XFILLER_79_110 VGND VGND VPWR VPWR sky130_fd_sc_hd__fill_2
XFILLER_4_386 VGND VGND VPWR VPWR sky130_fd_sc_hd__fill_1
XFILLER_106_292 VGND VGND VPWR VPWR sky130_fd_sc_hd__decap_3
XFILLER_79_143 VGND VGND VPWR VPWR sky130_fd_sc_hd__fill_1
XFILLER_95_603 VGND VGND VPWR VPWR sky130_fd_sc_hd__decap_3
XFILLER_67_316 VGND VGND VPWR VPWR sky130_fd_sc_hd__decap_3
XFILLER_0_570 VGND VGND VPWR VPWR sky130_fd_sc_hd__decap_3
XFILLER_0_581 VGND VGND VPWR VPWR sky130_fd_sc_hd__decap_3
XFILLER_95_647 VGND VGND VPWR VPWR sky130_fd_sc_hd__decap_3
XFILLER_94_124 VGND VGND VPWR VPWR sky130_fd_sc_hd__decap_3
XFILLER_79_198 VGND VGND VPWR VPWR sky130_fd_sc_hd__decap_3
XFILLER_121_295 VGND VGND VPWR VPWR sky130_fd_sc_hd__fill_1
XFILLER_0_592 VGND VGND VPWR VPWR sky130_fd_sc_hd__decap_3
XFILLER_48_541 VGND VGND VPWR VPWR sky130_fd_sc_hd__decap_3
XPHY_EDGE_ROW_121_Left_245 VGND VGND VPWR VPWR sky130_fd_sc_hd__decap_3
XFILLER_75_360 VGND VGND VPWR VPWR sky130_fd_sc_hd__decap_3
XFILLER_36_725 VGND VGND VPWR VPWR sky130_fd_sc_hd__decap_3
XFILLER_63_511 VGND VGND VPWR VPWR sky130_fd_sc_hd__decap_3
XFILLER_35_213 VGND VGND VPWR VPWR sky130_fd_sc_hd__decap_3
XFILLER_75_393 VGND VGND VPWR VPWR sky130_fd_sc_hd__decap_3
XFILLER_90_330 VGND VGND VPWR VPWR sky130_fd_sc_hd__decap_3
XFILLER_35_246 VGND VGND VPWR VPWR sky130_fd_sc_hd__decap_3
XFILLER_51_706 VGND VGND VPWR VPWR sky130_fd_sc_hd__decap_3
XFILLER_90_374 VGND VGND VPWR VPWR sky130_fd_sc_hd__decap_3
XFILLER_16_471 VGND VGND VPWR VPWR sky130_fd_sc_hd__decap_3
XTAP_TAPCELL_ROW_18_499 VGND VPWR sky130_fd_sc_hd__tapvpwrvgnd_1
XFILLER_50_249 VGND VGND VPWR VPWR sky130_fd_sc_hd__decap_3
X_6680_ _6680_/A VGND VGND VPWR VPWR _6680_/Y sky130_fd_sc_hd__inv_2
XFILLER_43_290 VGND VGND VPWR VPWR sky130_fd_sc_hd__decap_3
XFILLER_31_430 VGND VGND VPWR VPWR sky130_fd_sc_hd__decap_3
X_3892_ _6771_/Q _3892_/A2 _3892_/B1 _6765_/Q VGND VGND VPWR VPWR _3892_/X sky130_fd_sc_hd__a22o_2
XFILLER_31_441 VGND VGND VPWR VPWR sky130_fd_sc_hd__decap_3
XFILLER_31_452 VGND VGND VPWR VPWR sky130_fd_sc_hd__decap_3
XFILLER_31_485 VGND VGND VPWR VPWR sky130_fd_sc_hd__fill_2
X_7301_ _7365_/CLK _7301_/D _6581_/Y VGND VGND VPWR VPWR _7301_/Q sky130_fd_sc_hd__dfrtp_2
X_4513_ _4513_/A0 _4579_/A _4520_/S VGND VGND VPWR VPWR _7323_/D sky130_fd_sc_hd__mux2_2
XFILLER_8_681 VGND VGND VPWR VPWR sky130_fd_sc_hd__decap_3
XFILLER_117_535 VGND VGND VPWR VPWR sky130_fd_sc_hd__decap_3
X_7232_ _7359_/CLK _7232_/D _6512_/Y VGND VGND VPWR VPWR _7232_/Q sky130_fd_sc_hd__dfrtp_2
X_4444_ _4396_/A _4444_/B VGND VGND VPWR VPWR _4444_/X sky130_fd_sc_hd__and2b_2
Xclkbuf_leaf_7_clk clkload0/A VGND VGND VPWR VPWR _7378_/CLK sky130_fd_sc_hd__clkbuf_16
XFILLER_117_579 VGND VGND VPWR VPWR sky130_fd_sc_hd__decap_3
X_7163_ _7325_/CLK _7163_/D _6443_/Y VGND VGND VPWR VPWR _7163_/Q sky130_fd_sc_hd__dfrtp_2
X_4375_ _5003_/A _4374_/X _4988_/A VGND VGND VPWR VPWR _4375_/X sky130_fd_sc_hd__o21ba_2
XFILLER_98_430 VGND VGND VPWR VPWR sky130_fd_sc_hd__decap_3
XFILLER_98_463 VGND VGND VPWR VPWR sky130_fd_sc_hd__decap_3
X_3326_ _3326_/A _3326_/B VGND VGND VPWR VPWR _5238_/B sky130_fd_sc_hd__nor2_2
XFILLER_112_251 VGND VGND VPWR VPWR sky130_fd_sc_hd__fill_1
X_7094_ _7318_/CLK _7094_/D _6374_/Y VGND VGND VPWR VPWR _7094_/Q sky130_fd_sc_hd__dfrtp_2
XFILLER_86_625 VGND VGND VPWR VPWR sky130_fd_sc_hd__decap_3
XFILLER_85_113 VGND VGND VPWR VPWR sky130_fd_sc_hd__fill_1
XFILLER_100_424 VGND VGND VPWR VPWR sky130_fd_sc_hd__decap_3
XFILLER_58_349 VGND VGND VPWR VPWR sky130_fd_sc_hd__decap_3
XFILLER_86_669 VGND VGND VPWR VPWR sky130_fd_sc_hd__decap_3
XFILLER_85_146 VGND VGND VPWR VPWR sky130_fd_sc_hd__decap_3
XFILLER_73_308 VGND VGND VPWR VPWR sky130_fd_sc_hd__fill_2
XFILLER_27_703 VGND VGND VPWR VPWR sky130_fd_sc_hd__decap_3
XFILLER_66_360 VGND VGND VPWR VPWR sky130_fd_sc_hd__decap_3
XFILLER_66_371 VGND VGND VPWR VPWR sky130_fd_sc_hd__decap_3
XFILLER_39_596 VGND VGND VPWR VPWR sky130_fd_sc_hd__decap_3
XFILLER_54_533 VGND VGND VPWR VPWR sky130_fd_sc_hd__decap_3
XFILLER_26_235 VGND VGND VPWR VPWR sky130_fd_sc_hd__decap_3
XTAP_TAPCELL_ROW_107_1659 VGND VPWR sky130_fd_sc_hd__tapvpwrvgnd_1
XTAP_TAPCELL_ROW_37_742 VGND VPWR sky130_fd_sc_hd__tapvpwrvgnd_1
XTAP_TAPCELL_ROW_37_753 VGND VPWR sky130_fd_sc_hd__tapvpwrvgnd_1
XFILLER_42_728 VGND VGND VPWR VPWR sky130_fd_sc_hd__decap_3
XFILLER_14_419 VGND VGND VPWR VPWR sky130_fd_sc_hd__fill_1
XFILLER_81_374 VGND VGND VPWR VPWR sky130_fd_sc_hd__decap_3
X_6947_ _6965_/CLK _6947_/D VGND VGND VPWR VPWR _6947_/Q sky130_fd_sc_hd__dfxtp_2
XFILLER_81_385 VGND VGND VPWR VPWR sky130_fd_sc_hd__decap_3
XTAP_TAPCELL_ROW_120_1826 VGND VPWR sky130_fd_sc_hd__tapvpwrvgnd_1
XFILLER_22_430 VGND VGND VPWR VPWR sky130_fd_sc_hd__decap_3
X_6878_ clkload9/A _6878_/D VGND VGND VPWR VPWR _6878_/Q sky130_fd_sc_hd__dfxtp_2
XFILLER_22_452 VGND VGND VPWR VPWR sky130_fd_sc_hd__decap_3
XFILLER_10_625 VGND VGND VPWR VPWR sky130_fd_sc_hd__decap_3
XFILLER_6_607 VGND VGND VPWR VPWR sky130_fd_sc_hd__decap_3
XFILLER_10_669 VGND VGND VPWR VPWR sky130_fd_sc_hd__decap_3
XFILLER_108_513 VGND VGND VPWR VPWR sky130_fd_sc_hd__fill_2
XFILLER_108_557 VGND VGND VPWR VPWR sky130_fd_sc_hd__decap_3
XTAP_TAPCELL_ROW_118_1799 VGND VPWR sky130_fd_sc_hd__tapvpwrvgnd_1
XFILLER_123_516 VGND VGND VPWR VPWR sky130_fd_sc_hd__decap_3
XFILLER_118_53 VGND VGND VPWR VPWR sky130_fd_sc_hd__decap_3
XFILLER_1_301 VGND VGND VPWR VPWR sky130_fd_sc_hd__fill_1
XFILLER_78_35 VGND VGND VPWR VPWR sky130_fd_sc_hd__decap_3
XFILLER_118_97 VGND VGND VPWR VPWR sky130_fd_sc_hd__decap_3
Xhold670 _6722_/Q VGND VGND VPWR VPWR _6722_/D sky130_fd_sc_hd__dlygate4sd3_1
XFILLER_89_430 VGND VGND VPWR VPWR sky130_fd_sc_hd__decap_3
Xhold681 _6823_/Q VGND VGND VPWR VPWR _6823_/D sky130_fd_sc_hd__dlygate4sd3_1
Xhold692 _6729_/Q VGND VGND VPWR VPWR _6729_/D sky130_fd_sc_hd__dlygate4sd3_1
XFILLER_89_452 VGND VGND VPWR VPWR sky130_fd_sc_hd__decap_3
XFILLER_77_603 VGND VGND VPWR VPWR sky130_fd_sc_hd__decap_3
XFILLER_49_305 VGND VGND VPWR VPWR sky130_fd_sc_hd__decap_3
XFILLER_89_485 VGND VGND VPWR VPWR sky130_fd_sc_hd__decap_3
XFILLER_77_647 VGND VGND VPWR VPWR sky130_fd_sc_hd__decap_3
XFILLER_76_135 VGND VGND VPWR VPWR sky130_fd_sc_hd__decap_3
XFILLER_92_628 VGND VGND VPWR VPWR sky130_fd_sc_hd__decap_3
XFILLER_64_319 VGND VGND VPWR VPWR sky130_fd_sc_hd__fill_2
XFILLER_45_500 VGND VGND VPWR VPWR sky130_fd_sc_hd__decap_3
XFILLER_94_67 VGND VGND VPWR VPWR sky130_fd_sc_hd__decap_3
XFILLER_91_116 VGND VGND VPWR VPWR sky130_fd_sc_hd__fill_2
XFILLER_18_725 VGND VGND VPWR VPWR sky130_fd_sc_hd__decap_3
XFILLER_85_691 VGND VGND VPWR VPWR sky130_fd_sc_hd__decap_3
XFILLER_91_149 VGND VGND VPWR VPWR sky130_fd_sc_hd__fill_1
XFILLER_45_555 VGND VGND VPWR VPWR sky130_fd_sc_hd__fill_2
XFILLER_27_72 VGND VGND VPWR VPWR sky130_fd_sc_hd__fill_1
XFILLER_33_706 VGND VGND VPWR VPWR sky130_fd_sc_hd__decap_3
XFILLER_72_374 VGND VGND VPWR VPWR sky130_fd_sc_hd__decap_3
XFILLER_60_514 VGND VGND VPWR VPWR sky130_fd_sc_hd__decap_3
XFILLER_32_216 VGND VGND VPWR VPWR sky130_fd_sc_hd__decap_3
XFILLER_72_396 VGND VGND VPWR VPWR sky130_fd_sc_hd__decap_3
XFILLER_60_536 VGND VGND VPWR VPWR sky130_fd_sc_hd__decap_3
XFILLER_32_249 VGND VGND VPWR VPWR sky130_fd_sc_hd__decap_3
XFILLER_25_290 VGND VGND VPWR VPWR sky130_fd_sc_hd__decap_3
XTAP_TAPCELL_ROW_15_458 VGND VPWR sky130_fd_sc_hd__tapvpwrvgnd_1
XFILLER_13_452 VGND VGND VPWR VPWR sky130_fd_sc_hd__fill_2
XFILLER_43_82 VGND VGND VPWR VPWR sky130_fd_sc_hd__fill_2
XFILLER_9_434 VGND VGND VPWR VPWR sky130_fd_sc_hd__decap_3
XFILLER_9_467 VGND VGND VPWR VPWR sky130_fd_sc_hd__fill_1
XTAP_TAPCELL_ROW_97_1530 VGND VPWR sky130_fd_sc_hd__tapvpwrvgnd_1
XFILLER_57_6 VGND VGND VPWR VPWR sky130_fd_sc_hd__decap_3
XFILLER_5_662 VGND VGND VPWR VPWR sky130_fd_sc_hd__decap_3
XFILLER_5_673 VGND VGND VPWR VPWR sky130_fd_sc_hd__decap_3
XFILLER_4_32 VGND VGND VPWR VPWR sky130_fd_sc_hd__decap_3
X_4160_ _7297_/Q _4429_/A2 _4430_/B1 _7169_/Q _4159_/X VGND VGND VPWR VPWR _4160_/X
+ sky130_fd_sc_hd__a221o_2
XFILLER_122_560 VGND VGND VPWR VPWR sky130_fd_sc_hd__decap_3
XFILLER_68_625 VGND VGND VPWR VPWR sky130_fd_sc_hd__decap_3
XFILLER_95_411 VGND VGND VPWR VPWR sky130_fd_sc_hd__decap_3
XFILLER_110_722 VGND VGND VPWR VPWR sky130_fd_sc_hd__decap_3
XFILLER_67_113 VGND VGND VPWR VPWR sky130_fd_sc_hd__decap_3
XFILLER_95_444 VGND VGND VPWR VPWR sky130_fd_sc_hd__decap_3
X_4091_ _7110_/Q _4434_/A2 _4434_/B1 _7142_/Q _4090_/X VGND VGND VPWR VPWR _4091_/X
+ sky130_fd_sc_hd__a221o_2
XFILLER_95_455 VGND VGND VPWR VPWR sky130_fd_sc_hd__decap_3
XFILLER_68_669 VGND VGND VPWR VPWR sky130_fd_sc_hd__decap_3
XFILLER_83_606 VGND VGND VPWR VPWR sky130_fd_sc_hd__decap_3
XFILLER_67_157 VGND VGND VPWR VPWR sky130_fd_sc_hd__decap_3
XFILLER_83_617 VGND VGND VPWR VPWR sky130_fd_sc_hd__decap_3
XFILLER_55_319 VGND VGND VPWR VPWR sky130_fd_sc_hd__decap_3
XFILLER_48_360 VGND VGND VPWR VPWR sky130_fd_sc_hd__decap_3
XFILLER_82_116 VGND VGND VPWR VPWR sky130_fd_sc_hd__decap_3
XFILLER_75_190 VGND VGND VPWR VPWR sky130_fd_sc_hd__decap_3
XFILLER_91_650 VGND VGND VPWR VPWR sky130_fd_sc_hd__decap_3
XFILLER_63_352 VGND VGND VPWR VPWR sky130_fd_sc_hd__decap_3
X_6801_ _7403_/CLK _6801_/D VGND VGND VPWR VPWR _6801_/Q sky130_fd_sc_hd__dfxtp_2
Xplace330 _4460_/A VGND VGND VPWR VPWR _4205_/A sky130_fd_sc_hd__buf_2
XFILLER_24_728 VGND VGND VPWR VPWR sky130_fd_sc_hd__decap_3
XTAP_TAPCELL_ROW_34_712 VGND VPWR sky130_fd_sc_hd__tapvpwrvgnd_1
Xplace341 _4349_/B1 VGND VGND VPWR VPWR _4421_/A2 sky130_fd_sc_hd__buf_2
X_4993_ _4987_/A _4991_/Y _4992_/Y VGND VGND VPWR VPWR _4993_/X sky130_fd_sc_hd__o21a_2
Xplace352 _4337_/B VGND VGND VPWR VPWR _4108_/B sky130_fd_sc_hd__buf_2
XFILLER_91_694 VGND VGND VPWR VPWR sky130_fd_sc_hd__decap_3
Xplace363 _4267_/B1 VGND VGND VPWR VPWR _4436_/B1 sky130_fd_sc_hd__buf_2
XFILLER_23_238 VGND VGND VPWR VPWR sky130_fd_sc_hd__decap_3
Xplace374 _3860_/S VGND VGND VPWR VPWR _4799_/A sky130_fd_sc_hd__buf_2
X_6732_ clkload7/A _6732_/D VGND VGND VPWR VPWR _6732_/Q sky130_fd_sc_hd__dfxtp_2
Xplace385 _5229_/C VGND VGND VPWR VPWR _4341_/B1 sky130_fd_sc_hd__buf_2
XFILLER_16_290 VGND VGND VPWR VPWR sky130_fd_sc_hd__decap_3
Xplace396 _5344_/S VGND VGND VPWR VPWR _5315_/S sky130_fd_sc_hd__buf_2
X_6663_ _6664_/A VGND VGND VPWR VPWR _6663_/Y sky130_fd_sc_hd__inv_2
XTAP_TAPCELL_ROW_102_1589 VGND VPWR sky130_fd_sc_hd__tapvpwrvgnd_1
X_3875_ _3875_/A1 _3904_/A _3874_/X VGND VGND VPWR VPWR _7383_/D sky130_fd_sc_hd__o21a_2
XFILLER_31_293 VGND VGND VPWR VPWR sky130_fd_sc_hd__decap_3
X_6594_ _6594_/A VGND VGND VPWR VPWR _6594_/Y sky130_fd_sc_hd__inv_2
XFILLER_117_343 VGND VGND VPWR VPWR sky130_fd_sc_hd__fill_1
XTAP_TAPCELL_ROW_57_1002 VGND VPWR sky130_fd_sc_hd__tapvpwrvgnd_1
XTAP_TAPCELL_ROW_57_1013 VGND VPWR sky130_fd_sc_hd__tapvpwrvgnd_1
XFILLER_105_505 VGND VGND VPWR VPWR sky130_fd_sc_hd__decap_3
XFILLER_117_387 VGND VGND VPWR VPWR sky130_fd_sc_hd__decap_3
XFILLER_105_549 VGND VGND VPWR VPWR sky130_fd_sc_hd__decap_3
X_7215_ _7215_/CLK _7215_/D _6495_/Y VGND VGND VPWR VPWR _7215_/Q sky130_fd_sc_hd__dfrtp_2
XFILLER_59_603 VGND VGND VPWR VPWR sky130_fd_sc_hd__decap_3
X_7146_ _7372_/CLK _7146_/D _6426_/Y VGND VGND VPWR VPWR _7146_/Q sky130_fd_sc_hd__dfrtp_2
XFILLER_120_519 VGND VGND VPWR VPWR sky130_fd_sc_hd__decap_3
XFILLER_101_700 VGND VGND VPWR VPWR sky130_fd_sc_hd__decap_3
X_4358_ _4367_/A _4367_/B _4367_/C VGND VGND VPWR VPWR _5072_/B sky130_fd_sc_hd__a21bo_2
XFILLER_113_582 VGND VGND VPWR VPWR sky130_fd_sc_hd__decap_3
XFILLER_86_433 VGND VGND VPWR VPWR sky130_fd_sc_hd__decap_3
XFILLER_59_647 VGND VGND VPWR VPWR sky130_fd_sc_hd__decap_3
XFILLER_48_49 VGND VGND VPWR VPWR sky130_fd_sc_hd__fill_1
X_3309_ _3371_/A _6980_/Q _6979_/Q VGND VGND VPWR VPWR _3383_/B sky130_fd_sc_hd__or3_4
XFILLER_98_293 VGND VGND VPWR VPWR sky130_fd_sc_hd__fill_2
XFILLER_100_221 VGND VGND VPWR VPWR sky130_fd_sc_hd__decap_3
X_7077_ _7404_/CLK _7077_/D _6357_/Y VGND VGND VPWR VPWR _7077_/Q sky130_fd_sc_hd__dfrtp_2
X_4289_ _4289_/A _5708_/S VGND VGND VPWR VPWR _4649_/A sky130_fd_sc_hd__nand2_2
XFILLER_104_11 VGND VGND VPWR VPWR sky130_fd_sc_hd__decap_3
XFILLER_86_477 VGND VGND VPWR VPWR sky130_fd_sc_hd__fill_2
XFILLER_86_488 VGND VGND VPWR VPWR sky130_fd_sc_hd__decap_3
XFILLER_74_628 VGND VGND VPWR VPWR sky130_fd_sc_hd__decap_3
XFILLER_58_179 VGND VGND VPWR VPWR sky130_fd_sc_hd__decap_3
XFILLER_100_265 VGND VGND VPWR VPWR sky130_fd_sc_hd__decap_3
XFILLER_39_360 VGND VGND VPWR VPWR sky130_fd_sc_hd__decap_3
XFILLER_27_511 VGND VGND VPWR VPWR sky130_fd_sc_hd__decap_3
XFILLER_67_691 VGND VGND VPWR VPWR sky130_fd_sc_hd__decap_3
XFILLER_39_393 VGND VGND VPWR VPWR sky130_fd_sc_hd__decap_3
XFILLER_54_330 VGND VGND VPWR VPWR sky130_fd_sc_hd__decap_3
XTAP_TAPCELL_ROW_68_1153 VGND VPWR sky130_fd_sc_hd__tapvpwrvgnd_1
XFILLER_15_706 VGND VGND VPWR VPWR sky130_fd_sc_hd__decap_3
XFILLER_82_672 VGND VGND VPWR VPWR sky130_fd_sc_hd__decap_3
XFILLER_42_525 VGND VGND VPWR VPWR sky130_fd_sc_hd__decap_3
XFILLER_27_599 VGND VGND VPWR VPWR sky130_fd_sc_hd__decap_3
XFILLER_54_396 VGND VGND VPWR VPWR sky130_fd_sc_hd__decap_3
XFILLER_120_32 VGND VGND VPWR VPWR sky130_fd_sc_hd__decap_3
XTAP_TAPCELL_ROW_81_1320 VGND VPWR sky130_fd_sc_hd__tapvpwrvgnd_1
Xfanout20 _6662_/A VGND VGND VPWR VPWR _6667_/A sky130_fd_sc_hd__buf_1
Xfanout31 _6603_/A VGND VGND VPWR VPWR _6370_/A sky130_fd_sc_hd__buf_1
XFILLER_120_65 VGND VGND VPWR VPWR sky130_fd_sc_hd__decap_3
Xfanout42 fanout46/X VGND VGND VPWR VPWR _6638_/A sky130_fd_sc_hd__buf_2
Xfanout53 _6646_/A VGND VGND VPWR VPWR _6643_/A sky130_fd_sc_hd__buf_2
XTAP_TAPCELL_ROW_12_417 VGND VPWR sky130_fd_sc_hd__tapvpwrvgnd_1
Xfanout64 _6622_/A VGND VGND VPWR VPWR _6618_/A sky130_fd_sc_hd__buf_2
XTAP_TAPCELL_ROW_12_428 VGND VPWR sky130_fd_sc_hd__tapvpwrvgnd_1
Xfanout75 _6350_/A VGND VGND VPWR VPWR _6288_/A sky130_fd_sc_hd__clkdlybuf4s25_1
XFILLER_22_271 VGND VGND VPWR VPWR sky130_fd_sc_hd__decap_3
XFILLER_13_63 VGND VGND VPWR VPWR sky130_fd_sc_hd__fill_1
XFILLER_10_477 VGND VGND VPWR VPWR sky130_fd_sc_hd__fill_1
XFILLER_89_12 VGND VGND VPWR VPWR sky130_fd_sc_hd__decap_3
XFILLER_108_365 VGND VGND VPWR VPWR sky130_fd_sc_hd__decap_3
XTAP_TAPCELL_ROW_79_1293 VGND VPWR sky130_fd_sc_hd__tapvpwrvgnd_1
XFILLER_108_376 VGND VGND VPWR VPWR sky130_fd_sc_hd__decap_3
XFILLER_123_302 VGND VGND VPWR VPWR sky130_fd_sc_hd__decap_3
XFILLER_123_335 VGND VGND VPWR VPWR sky130_fd_sc_hd__fill_1
XFILLER_97_709 VGND VGND VPWR VPWR sky130_fd_sc_hd__decap_3
XFILLER_2_632 VGND VGND VPWR VPWR sky130_fd_sc_hd__decap_3
XTAP_TAPCELL_ROW_92_1460 VGND VPWR sky130_fd_sc_hd__tapvpwrvgnd_1
XFILLER_2_654 VGND VGND VPWR VPWR sky130_fd_sc_hd__decap_3
XFILLER_96_208 VGND VGND VPWR VPWR sky130_fd_sc_hd__decap_3
XFILLER_123_368 VGND VGND VPWR VPWR sky130_fd_sc_hd__decap_3
XFILLER_111_519 VGND VGND VPWR VPWR sky130_fd_sc_hd__decap_3
XFILLER_104_560 VGND VGND VPWR VPWR sky130_fd_sc_hd__decap_3
XFILLER_2_687 VGND VGND VPWR VPWR sky130_fd_sc_hd__decap_3
XFILLER_89_293 VGND VGND VPWR VPWR sky130_fd_sc_hd__decap_3
XFILLER_1_197 VGND VGND VPWR VPWR sky130_fd_sc_hd__decap_3
XFILLER_65_617 VGND VGND VPWR VPWR sky130_fd_sc_hd__decap_3
XFILLER_77_488 VGND VGND VPWR VPWR sky130_fd_sc_hd__decap_3
XFILLER_37_319 VGND VGND VPWR VPWR sky130_fd_sc_hd__decap_3
XFILLER_38_93 VGND VGND VPWR VPWR sky130_fd_sc_hd__decap_3
XFILLER_92_447 VGND VGND VPWR VPWR sky130_fd_sc_hd__decap_3
XFILLER_18_533 VGND VGND VPWR VPWR sky130_fd_sc_hd__decap_3
XFILLER_64_149 VGND VGND VPWR VPWR sky130_fd_sc_hd__decap_3
XFILLER_73_650 VGND VGND VPWR VPWR sky130_fd_sc_hd__decap_3
XFILLER_18_566 VGND VGND VPWR VPWR sky130_fd_sc_hd__decap_3
XFILLER_73_694 VGND VGND VPWR VPWR sky130_fd_sc_hd__decap_3
XFILLER_72_171 VGND VGND VPWR VPWR sky130_fd_sc_hd__decap_3
XFILLER_45_396 VGND VGND VPWR VPWR sky130_fd_sc_hd__decap_3
XFILLER_60_344 VGND VGND VPWR VPWR sky130_fd_sc_hd__decap_3
XFILLER_21_709 VGND VGND VPWR VPWR sky130_fd_sc_hd__decap_3
XFILLER_60_377 VGND VGND VPWR VPWR sky130_fd_sc_hd__decap_3
XFILLER_20_208 VGND VGND VPWR VPWR sky130_fd_sc_hd__decap_3
XFILLER_13_293 VGND VGND VPWR VPWR sky130_fd_sc_hd__decap_3
XFILLER_9_242 VGND VGND VPWR VPWR sky130_fd_sc_hd__decap_3
XFILLER_9_275 VGND VGND VPWR VPWR sky130_fd_sc_hd__decap_3
Xclkload12 _7313_/CLK VGND VGND VPWR VPWR clkload12/Y sky130_fd_sc_hd__clkinv_2
Xclkload23 _7405_/CLK VGND VGND VPWR VPWR clkload23/Y sky130_fd_sc_hd__bufinv_16
X_3591_ _3591_/A _3591_/B _3591_/C _3586_/D VGND VGND VPWR VPWR _3591_/Y sky130_fd_sc_hd__nor4b_2
Xclkload34 _7395_/CLK VGND VGND VPWR VPWR clkload34/X sky130_fd_sc_hd__clkbuf_1
XFILLER_55_3 VGND VGND VPWR VPWR sky130_fd_sc_hd__decap_3
XFILLER_114_357 VGND VGND VPWR VPWR sky130_fd_sc_hd__fill_2
X_7000_ _7370_/CLK _7000_/D _6280_/Y VGND VGND VPWR VPWR _7000_/Q sky130_fd_sc_hd__dfrtp_2
X_4212_ _7324_/Q _3964_/S _4348_/B1 _7132_/Q VGND VGND VPWR VPWR _4212_/X sky130_fd_sc_hd__a22o_2
X_5192_ _5192_/A _5207_/B VGND VGND VPWR VPWR _7232_/D sky130_fd_sc_hd__and2_2
XFILLER_96_731 VGND VGND VPWR VPWR sky130_fd_sc_hd__decap_3
XFILLER_68_433 VGND VGND VPWR VPWR sky130_fd_sc_hd__decap_3
X_4143_ _4845_/A _4140_/X _4142_/X VGND VGND VPWR VPWR _4143_/X sky130_fd_sc_hd__a21o_2
XFILLER_110_530 VGND VGND VPWR VPWR sky130_fd_sc_hd__fill_2
XFILLER_68_466 VGND VGND VPWR VPWR sky130_fd_sc_hd__decap_3
XFILLER_95_263 VGND VGND VPWR VPWR sky130_fd_sc_hd__decap_3
XFILLER_68_477 VGND VGND VPWR VPWR sky130_fd_sc_hd__decap_3
XFILLER_110_563 VGND VGND VPWR VPWR sky130_fd_sc_hd__decap_3
XFILLER_56_628 VGND VGND VPWR VPWR sky130_fd_sc_hd__decap_3
XFILLER_55_105 VGND VGND VPWR VPWR sky130_fd_sc_hd__decap_3
X_4074_ _7083_/Q _4102_/B _4432_/B1 _4073_/X VGND VGND VPWR VPWR _4451_/A sky130_fd_sc_hd__o211ai_2
XFILLER_95_296 VGND VGND VPWR VPWR sky130_fd_sc_hd__fill_1
XFILLER_49_691 VGND VGND VPWR VPWR sky130_fd_sc_hd__decap_3
XFILLER_83_458 VGND VGND VPWR VPWR sky130_fd_sc_hd__decap_3
XFILLER_36_330 VGND VGND VPWR VPWR sky130_fd_sc_hd__decap_3
XFILLER_64_672 VGND VGND VPWR VPWR sky130_fd_sc_hd__decap_3
XFILLER_36_363 VGND VGND VPWR VPWR sky130_fd_sc_hd__fill_1
XFILLER_70_119 VGND VGND VPWR VPWR sky130_fd_sc_hd__decap_3
XTAP_TAPCELL_ROW_104_1618 VGND VPWR sky130_fd_sc_hd__tapvpwrvgnd_1
XFILLER_36_374 VGND VGND VPWR VPWR sky130_fd_sc_hd__decap_3
XTAP_TAPCELL_ROW_47_881 VGND VPWR sky130_fd_sc_hd__tapvpwrvgnd_1
XFILLER_51_311 VGND VGND VPWR VPWR sky130_fd_sc_hd__decap_3
XFILLER_24_536 VGND VGND VPWR VPWR sky130_fd_sc_hd__fill_2
XFILLER_51_333 VGND VGND VPWR VPWR sky130_fd_sc_hd__decap_3
XFILLER_63_193 VGND VGND VPWR VPWR sky130_fd_sc_hd__decap_3
XFILLER_24_569 VGND VGND VPWR VPWR sky130_fd_sc_hd__decap_3
X_4976_ _6992_/Q _5001_/A _6993_/Q VGND VGND VPWR VPWR _4977_/B sky130_fd_sc_hd__a21oi_2
X_6715_ _7403_/CLK _6715_/D VGND VGND VPWR VPWR _6715_/Q sky130_fd_sc_hd__dfxtp_2
X_3927_ _3682_/A _3926_/X _4791_/A1 VGND VGND VPWR VPWR _3927_/X sky130_fd_sc_hd__a21o_2
XFILLER_51_399 VGND VGND VPWR VPWR sky130_fd_sc_hd__decap_3
XFILLER_32_580 VGND VGND VPWR VPWR sky130_fd_sc_hd__decap_3
XTAP_TAPCELL_ROW_63_1083 VGND VPWR sky130_fd_sc_hd__tapvpwrvgnd_1
XFILLER_20_731 VGND VGND VPWR VPWR sky130_fd_sc_hd__decap_3
Xclkload6 clkload6/A VGND VGND VPWR VPWR clkload6/Y sky130_fd_sc_hd__inv_6
X_3858_ _6698_/Q _3925_/A2 _3925_/B1 _6876_/Q VGND VGND VPWR VPWR _3858_/X sky130_fd_sc_hd__a22o_2
X_6646_ _6646_/A VGND VGND VPWR VPWR _6646_/Y sky130_fd_sc_hd__inv_2
X_3789_ _3728_/Y _3781_/X _3783_/X _3725_/X _3788_/X VGND VGND VPWR VPWR _3789_/X
+ sky130_fd_sc_hd__a221o_2
X_6577_ _6610_/A VGND VGND VPWR VPWR _6577_/Y sky130_fd_sc_hd__inv_2
XFILLER_118_663 VGND VGND VPWR VPWR sky130_fd_sc_hd__decap_3
XFILLER_117_151 VGND VGND VPWR VPWR sky130_fd_sc_hd__decap_3
XFILLER_118_696 VGND VGND VPWR VPWR sky130_fd_sc_hd__decap_3
XTAP_TAPCELL_ROW_115_1758 VGND VPWR sky130_fd_sc_hd__tapvpwrvgnd_1
XFILLER_79_709 VGND VGND VPWR VPWR sky130_fd_sc_hd__decap_3
XFILLER_105_346 VGND VGND VPWR VPWR sky130_fd_sc_hd__fill_2
Xoutput550 _6985_/Q VGND VGND VPWR VPWR pc_out[8] sky130_fd_sc_hd__clkdlybuf4s25_1
XFILLER_120_305 VGND VGND VPWR VPWR sky130_fd_sc_hd__decap_3
XFILLER_105_379 VGND VGND VPWR VPWR sky130_fd_sc_hd__decap_3
XFILLER_59_411 VGND VGND VPWR VPWR sky130_fd_sc_hd__decap_3
XFILLER_115_10 VGND VGND VPWR VPWR sky130_fd_sc_hd__decap_3
XFILLER_99_591 VGND VGND VPWR VPWR sky130_fd_sc_hd__decap_3
X_7129_ _7356_/CLK _7129_/D _6409_/Y VGND VGND VPWR VPWR _7129_/Q sky130_fd_sc_hd__dfrtp_2
XFILLER_86_230 VGND VGND VPWR VPWR sky130_fd_sc_hd__decap_3
XFILLER_115_43 VGND VGND VPWR VPWR sky130_fd_sc_hd__decap_3
XFILLER_59_455 VGND VGND VPWR VPWR sky130_fd_sc_hd__decap_3
XFILLER_101_552 VGND VGND VPWR VPWR sky130_fd_sc_hd__decap_3
XFILLER_47_617 VGND VGND VPWR VPWR sky130_fd_sc_hd__decap_3
XFILLER_19_319 VGND VGND VPWR VPWR sky130_fd_sc_hd__fill_1
XFILLER_115_87 VGND VGND VPWR VPWR sky130_fd_sc_hd__decap_3
XFILLER_86_274 VGND VGND VPWR VPWR sky130_fd_sc_hd__decap_3
XFILLER_46_105 VGND VGND VPWR VPWR sky130_fd_sc_hd__decap_3
XFILLER_101_585 VGND VGND VPWR VPWR sky130_fd_sc_hd__decap_3
XFILLER_86_296 VGND VGND VPWR VPWR sky130_fd_sc_hd__decap_3
XFILLER_75_69 VGND VGND VPWR VPWR sky130_fd_sc_hd__decap_3
XFILLER_55_650 VGND VGND VPWR VPWR sky130_fd_sc_hd__decap_3
XFILLER_27_352 VGND VGND VPWR VPWR sky130_fd_sc_hd__decap_3
XFILLER_15_514 VGND VGND VPWR VPWR sky130_fd_sc_hd__decap_3
XFILLER_82_480 VGND VGND VPWR VPWR sky130_fd_sc_hd__decap_3
XFILLER_55_694 VGND VGND VPWR VPWR sky130_fd_sc_hd__decap_3
XFILLER_27_385 VGND VGND VPWR VPWR sky130_fd_sc_hd__fill_2
XFILLER_27_396 VGND VGND VPWR VPWR sky130_fd_sc_hd__decap_3
XFILLER_70_631 VGND VGND VPWR VPWR sky130_fd_sc_hd__decap_3
XFILLER_15_547 VGND VGND VPWR VPWR sky130_fd_sc_hd__decap_3
XFILLER_54_193 VGND VGND VPWR VPWR sky130_fd_sc_hd__decap_3
XFILLER_91_57 VGND VGND VPWR VPWR sky130_fd_sc_hd__decap_3
XFILLER_70_675 VGND VGND VPWR VPWR sky130_fd_sc_hd__decap_3
XTAP_TAPCELL_ROW_25_586 VGND VPWR sky130_fd_sc_hd__tapvpwrvgnd_1
XFILLER_42_399 VGND VGND VPWR VPWR sky130_fd_sc_hd__decap_3
XTAP_TAPCELL_ROW_25_597 VGND VPWR sky130_fd_sc_hd__tapvpwrvgnd_1
XFILLER_24_73 VGND VGND VPWR VPWR sky130_fd_sc_hd__fill_1
XFILLER_23_580 VGND VGND VPWR VPWR sky130_fd_sc_hd__decap_3
XFILLER_10_241 VGND VGND VPWR VPWR sky130_fd_sc_hd__fill_1
XFILLER_7_724 VGND VGND VPWR VPWR sky130_fd_sc_hd__decap_3
XFILLER_6_212 VGND VGND VPWR VPWR sky130_fd_sc_hd__decap_3
XFILLER_6_223 VGND VGND VPWR VPWR sky130_fd_sc_hd__decap_3
XFILLER_10_274 VGND VGND VPWR VPWR sky130_fd_sc_hd__decap_3
XFILLER_109_641 VGND VGND VPWR VPWR sky130_fd_sc_hd__decap_3
XFILLER_6_256 VGND VGND VPWR VPWR sky130_fd_sc_hd__fill_1
XFILLER_109_685 VGND VGND VPWR VPWR sky130_fd_sc_hd__decap_3
XFILLER_108_162 VGND VGND VPWR VPWR sky130_fd_sc_hd__decap_3
XFILLER_6_289 VGND VGND VPWR VPWR sky130_fd_sc_hd__decap_3
XFILLER_123_110 VGND VGND VPWR VPWR sky130_fd_sc_hd__fill_2
XFILLER_69_208 VGND VGND VPWR VPWR sky130_fd_sc_hd__decap_3
XFILLER_69_219 VGND VGND VPWR VPWR sky130_fd_sc_hd__decap_3
XFILLER_111_305 VGND VGND VPWR VPWR sky130_fd_sc_hd__decap_3
XFILLER_78_731 VGND VGND VPWR VPWR sky130_fd_sc_hd__decap_3
XFILLER_93_712 VGND VGND VPWR VPWR sky130_fd_sc_hd__decap_3
XFILLER_38_628 VGND VGND VPWR VPWR sky130_fd_sc_hd__decap_3
XFILLER_77_274 VGND VGND VPWR VPWR sky130_fd_sc_hd__decap_3
XFILLER_92_211 VGND VGND VPWR VPWR sky130_fd_sc_hd__decap_3
XFILLER_65_425 VGND VGND VPWR VPWR sky130_fd_sc_hd__decap_3
XFILLER_77_296 VGND VGND VPWR VPWR sky130_fd_sc_hd__decap_3
XFILLER_92_244 VGND VGND VPWR VPWR sky130_fd_sc_hd__decap_3
XFILLER_53_609 VGND VGND VPWR VPWR sky130_fd_sc_hd__decap_3
XFILLER_80_406 VGND VGND VPWR VPWR sky130_fd_sc_hd__fill_2
XFILLER_18_352 VGND VGND VPWR VPWR sky130_fd_sc_hd__decap_3
XFILLER_92_277 VGND VGND VPWR VPWR sky130_fd_sc_hd__decap_3
XFILLER_46_672 VGND VGND VPWR VPWR sky130_fd_sc_hd__decap_3
XFILLER_18_385 VGND VGND VPWR VPWR sky130_fd_sc_hd__decap_3
XFILLER_61_620 VGND VGND VPWR VPWR sky130_fd_sc_hd__decap_3
XFILLER_33_322 VGND VGND VPWR VPWR sky130_fd_sc_hd__decap_3
XFILLER_45_193 VGND VGND VPWR VPWR sky130_fd_sc_hd__decap_3
XTAP_TAPCELL_ROW_44_840 VGND VPWR sky130_fd_sc_hd__tapvpwrvgnd_1
XFILLER_61_653 VGND VGND VPWR VPWR sky130_fd_sc_hd__decap_3
X_4830_ _4646_/Y _4827_/A _4829_/Y VGND VGND VPWR VPWR _4830_/X sky130_fd_sc_hd__o21a_2
XFILLER_60_130 VGND VGND VPWR VPWR sky130_fd_sc_hd__fill_2
XFILLER_33_355 VGND VGND VPWR VPWR sky130_fd_sc_hd__decap_3
XFILLER_60_141 VGND VGND VPWR VPWR sky130_fd_sc_hd__fill_2
XFILLER_33_366 VGND VGND VPWR VPWR sky130_fd_sc_hd__decap_3
XFILLER_61_697 VGND VGND VPWR VPWR sky130_fd_sc_hd__decap_3
XFILLER_60_174 VGND VGND VPWR VPWR sky130_fd_sc_hd__decap_3
X_4761_ _4762_/B _4761_/B _4761_/C VGND VGND VPWR VPWR _4761_/Y sky130_fd_sc_hd__nand3_2
X_3712_ _3746_/B VGND VGND VPWR VPWR _3741_/B sky130_fd_sc_hd__inv_2
X_6500_ _6596_/A VGND VGND VPWR VPWR _6500_/Y sky130_fd_sc_hd__inv_2
XFILLER_119_405 VGND VGND VPWR VPWR sky130_fd_sc_hd__decap_3
X_4692_ _7006_/Q _4749_/B VGND VGND VPWR VPWR _4750_/B sky130_fd_sc_hd__and2_2
XFILLER_119_438 VGND VGND VPWR VPWR sky130_fd_sc_hd__decap_3
XFILLER_119_449 VGND VGND VPWR VPWR sky130_fd_sc_hd__fill_2
X_6431_ _6591_/A VGND VGND VPWR VPWR _6431_/Y sky130_fd_sc_hd__inv_2
X_6362_ _6363_/A VGND VGND VPWR VPWR _6362_/Y sky130_fd_sc_hd__inv_2
XFILLER_115_600 VGND VGND VPWR VPWR sky130_fd_sc_hd__decap_3
X_3574_ _7348_/Q _4278_/B1 _3573_/X _3556_/A VGND VGND VPWR VPWR _3574_/X sky130_fd_sc_hd__a211o_2
XFILLER_115_644 VGND VGND VPWR VPWR sky130_fd_sc_hd__decap_3
X_6293_ _6602_/A VGND VGND VPWR VPWR _6293_/Y sky130_fd_sc_hd__inv_2
XFILLER_115_688 VGND VGND VPWR VPWR sky130_fd_sc_hd__decap_3
XFILLER_114_176 VGND VGND VPWR VPWR sky130_fd_sc_hd__decap_3
XFILLER_102_316 VGND VGND VPWR VPWR sky130_fd_sc_hd__decap_3
XFILLER_29_29 VGND VGND VPWR VPWR sky130_fd_sc_hd__fill_1
X_5175_ _5175_/A _5207_/B VGND VGND VPWR VPWR _7240_/D sky130_fd_sc_hd__and2_2
XFILLER_84_701 VGND VGND VPWR VPWR sky130_fd_sc_hd__decap_3
XFILLER_96_572 VGND VGND VPWR VPWR sky130_fd_sc_hd__decap_3
XFILLER_29_617 VGND VGND VPWR VPWR sky130_fd_sc_hd__decap_3
XTAP_TAPCELL_ROW_110_1699 VGND VPWR sky130_fd_sc_hd__tapvpwrvgnd_1
X_4126_ _4126_/A _4125_/X VGND VGND VPWR VPWR _4890_/B sky130_fd_sc_hd__or2b_2
XFILLER_68_274 VGND VGND VPWR VPWR sky130_fd_sc_hd__decap_3
XFILLER_56_414 VGND VGND VPWR VPWR sky130_fd_sc_hd__decap_3
XFILLER_84_734 VGND VGND VPWR VPWR sky130_fd_sc_hd__fill_1
XFILLER_83_222 VGND VGND VPWR VPWR sky130_fd_sc_hd__fill_2
XFILLER_56_436 VGND VGND VPWR VPWR sky130_fd_sc_hd__decap_3
X_4057_ _7308_/Q _4488_/S _4437_/B1 _7372_/Q _4429_/C1 VGND VGND VPWR VPWR _4057_/X
+ sky130_fd_sc_hd__a221o_2
XFILLER_56_469 VGND VGND VPWR VPWR sky130_fd_sc_hd__fill_2
XFILLER_44_609 VGND VGND VPWR VPWR sky130_fd_sc_hd__decap_3
XFILLER_83_255 VGND VGND VPWR VPWR sky130_fd_sc_hd__decap_3
XFILLER_37_650 VGND VGND VPWR VPWR sky130_fd_sc_hd__decap_3
XFILLER_45_28 VGND VGND VPWR VPWR sky130_fd_sc_hd__fill_1
XFILLER_71_417 VGND VGND VPWR VPWR sky130_fd_sc_hd__decap_3
XTAP_TAPCELL_ROW_65_1112 VGND VPWR sky130_fd_sc_hd__tapvpwrvgnd_1
XFILLER_64_480 VGND VGND VPWR VPWR sky130_fd_sc_hd__decap_3
XFILLER_37_694 VGND VGND VPWR VPWR sky130_fd_sc_hd__decap_3
XFILLER_52_631 VGND VGND VPWR VPWR sky130_fd_sc_hd__decap_3
XFILLER_24_322 VGND VGND VPWR VPWR sky130_fd_sc_hd__decap_3
XFILLER_52_675 VGND VGND VPWR VPWR sky130_fd_sc_hd__decap_3
X_4959_ _6993_/Q _4958_/Y _6994_/Q VGND VGND VPWR VPWR _4960_/C sky130_fd_sc_hd__a21oi_2
XFILLER_51_196 VGND VGND VPWR VPWR sky130_fd_sc_hd__decap_3
XTAP_TAPCELL_ROW_22_556 VGND VPWR sky130_fd_sc_hd__tapvpwrvgnd_1
XFILLER_20_572 VGND VGND VPWR VPWR sky130_fd_sc_hd__decap_3
X_6629_ _6630_/A VGND VGND VPWR VPWR _6629_/Y sky130_fd_sc_hd__inv_2
XFILLER_4_716 VGND VGND VPWR VPWR sky130_fd_sc_hd__decap_3
XFILLER_106_622 VGND VGND VPWR VPWR sky130_fd_sc_hd__decap_3
XFILLER_3_215 VGND VGND VPWR VPWR sky130_fd_sc_hd__decap_3
XTAP_TAPCELL_ROW_76_1252 VGND VPWR sky130_fd_sc_hd__tapvpwrvgnd_1
XFILLER_3_237 VGND VGND VPWR VPWR sky130_fd_sc_hd__fill_1
XFILLER_106_666 VGND VGND VPWR VPWR sky130_fd_sc_hd__decap_3
XFILLER_121_603 VGND VGND VPWR VPWR sky130_fd_sc_hd__decap_3
XFILLER_106_699 VGND VGND VPWR VPWR sky130_fd_sc_hd__fill_1
XFILLER_121_647 VGND VGND VPWR VPWR sky130_fd_sc_hd__decap_3
XFILLER_105_198 VGND VGND VPWR VPWR sky130_fd_sc_hd__decap_3
XFILLER_86_35 VGND VGND VPWR VPWR sky130_fd_sc_hd__decap_3
XFILLER_87_561 VGND VGND VPWR VPWR sky130_fd_sc_hd__decap_3
XFILLER_75_712 VGND VGND VPWR VPWR sky130_fd_sc_hd__decap_3
XFILLER_74_200 VGND VGND VPWR VPWR sky130_fd_sc_hd__decap_3
XFILLER_59_274 VGND VGND VPWR VPWR sky130_fd_sc_hd__decap_3
XFILLER_87_594 VGND VGND VPWR VPWR sky130_fd_sc_hd__decap_3
XFILLER_19_116 VGND VGND VPWR VPWR sky130_fd_sc_hd__decap_3
XFILLER_101_371 VGND VGND VPWR VPWR sky130_fd_sc_hd__decap_3
XFILLER_101_382 VGND VGND VPWR VPWR sky130_fd_sc_hd__fill_2
XFILLER_101_393 VGND VGND VPWR VPWR sky130_fd_sc_hd__decap_3
XFILLER_35_609 VGND VGND VPWR VPWR sky130_fd_sc_hd__decap_3
XFILLER_90_704 VGND VGND VPWR VPWR sky130_fd_sc_hd__decap_3
XFILLER_62_406 VGND VGND VPWR VPWR sky130_fd_sc_hd__decap_3
XFILLER_28_672 VGND VGND VPWR VPWR sky130_fd_sc_hd__decap_3
XTAP_TAPCELL_ROW_2_292 VGND VPWR sky130_fd_sc_hd__tapvpwrvgnd_1
XFILLER_74_299 VGND VGND VPWR VPWR sky130_fd_sc_hd__decap_3
XFILLER_62_439 VGND VGND VPWR VPWR sky130_fd_sc_hd__decap_3
XFILLER_43_620 VGND VGND VPWR VPWR sky130_fd_sc_hd__decap_3
XTAP_TAPCELL_ROW_87_1392 VGND VPWR sky130_fd_sc_hd__tapvpwrvgnd_1
XFILLER_27_193 VGND VGND VPWR VPWR sky130_fd_sc_hd__decap_3
XFILLER_15_333 VGND VGND VPWR VPWR sky130_fd_sc_hd__decap_3
XFILLER_43_653 VGND VGND VPWR VPWR sky130_fd_sc_hd__decap_3
XFILLER_42_141 VGND VGND VPWR VPWR sky130_fd_sc_hd__fill_2
XFILLER_70_483 VGND VGND VPWR VPWR sky130_fd_sc_hd__decap_3
XFILLER_43_697 VGND VGND VPWR VPWR sky130_fd_sc_hd__decap_3
XFILLER_42_185 VGND VGND VPWR VPWR sky130_fd_sc_hd__decap_3
XFILLER_15_399 VGND VGND VPWR VPWR sky130_fd_sc_hd__decap_3
XFILLER_89_9 VGND VGND VPWR VPWR sky130_fd_sc_hd__decap_3
XFILLER_30_358 VGND VGND VPWR VPWR sky130_fd_sc_hd__decap_3
XFILLER_11_550 VGND VGND VPWR VPWR sky130_fd_sc_hd__decap_3
XFILLER_11_561 VGND VGND VPWR VPWR sky130_fd_sc_hd__decap_3
XFILLER_11_594 VGND VGND VPWR VPWR sky130_fd_sc_hd__decap_3
XFILLER_7_554 VGND VGND VPWR VPWR sky130_fd_sc_hd__decap_3
XFILLER_7_576 VGND VGND VPWR VPWR sky130_fd_sc_hd__decap_3
XFILLER_116_419 VGND VGND VPWR VPWR sky130_fd_sc_hd__fill_1
XFILLER_109_482 VGND VGND VPWR VPWR sky130_fd_sc_hd__decap_3
XFILLER_97_314 VGND VGND VPWR VPWR sky130_fd_sc_hd__decap_3
XFILLER_112_625 VGND VGND VPWR VPWR sky130_fd_sc_hd__decap_3
XFILLER_111_113 VGND VGND VPWR VPWR sky130_fd_sc_hd__decap_3
XFILLER_97_358 VGND VGND VPWR VPWR sky130_fd_sc_hd__decap_3
XFILLER_112_669 VGND VGND VPWR VPWR sky130_fd_sc_hd__decap_3
XFILLER_66_701 VGND VGND VPWR VPWR sky130_fd_sc_hd__decap_3
XFILLER_78_572 VGND VGND VPWR VPWR sky130_fd_sc_hd__fill_1
XTAP_TAPCELL_ROW_49_910 VGND VPWR sky130_fd_sc_hd__tapvpwrvgnd_1
XFILLER_66_734 VGND VGND VPWR VPWR sky130_fd_sc_hd__fill_1
XFILLER_65_222 VGND VGND VPWR VPWR sky130_fd_sc_hd__fill_2
XFILLER_93_553 VGND VGND VPWR VPWR sky130_fd_sc_hd__decap_3
XFILLER_93_564 VGND VGND VPWR VPWR sky130_fd_sc_hd__decap_3
XFILLER_65_255 VGND VGND VPWR VPWR sky130_fd_sc_hd__decap_3
XFILLER_19_650 VGND VGND VPWR VPWR sky130_fd_sc_hd__decap_3
X_6980_ clkload6/A _6980_/D _6260_/Y VGND VGND VPWR VPWR _6980_/Q sky130_fd_sc_hd__dfrtp_2
XFILLER_81_715 VGND VGND VPWR VPWR sky130_fd_sc_hd__decap_3
XFILLER_53_406 VGND VGND VPWR VPWR sky130_fd_sc_hd__decap_3
XFILLER_80_203 VGND VGND VPWR VPWR sky130_fd_sc_hd__decap_3
XFILLER_93_597 VGND VGND VPWR VPWR sky130_fd_sc_hd__decap_3
XFILLER_80_225 VGND VGND VPWR VPWR sky130_fd_sc_hd__decap_3
XFILLER_65_299 VGND VGND VPWR VPWR sky130_fd_sc_hd__decap_3
XFILLER_19_694 VGND VGND VPWR VPWR sky130_fd_sc_hd__decap_3
XFILLER_46_480 VGND VGND VPWR VPWR sky130_fd_sc_hd__fill_2
XFILLER_46_491 VGND VGND VPWR VPWR sky130_fd_sc_hd__fill_2
XFILLER_34_631 VGND VGND VPWR VPWR sky130_fd_sc_hd__decap_3
XFILLER_34_675 VGND VGND VPWR VPWR sky130_fd_sc_hd__decap_3
XFILLER_33_152 VGND VGND VPWR VPWR sky130_fd_sc_hd__decap_3
X_4813_ _4813_/A _4813_/B VGND VGND VPWR VPWR _4813_/Y sky130_fd_sc_hd__nand2_2
XFILLER_21_347 VGND VGND VPWR VPWR sky130_fd_sc_hd__decap_3
XTAP_TAPCELL_ROW_60_1042 VGND VPWR sky130_fd_sc_hd__tapvpwrvgnd_1
X_4744_ _4938_/A _4744_/B VGND VGND VPWR VPWR _4744_/Y sky130_fd_sc_hd__nor2_2
XTAP_TAPCELL_ROW_60_1053 VGND VPWR sky130_fd_sc_hd__tapvpwrvgnd_1
X_4675_ _3469_/A _3469_/B _3564_/X _3449_/A _6984_/Q VGND VGND VPWR VPWR _5067_/B
+ sky130_fd_sc_hd__o2111a_2
X_3626_ _3616_/Y _3617_/X _3625_/X VGND VGND VPWR VPWR _3733_/C sky130_fd_sc_hd__a21oi_4
X_6414_ _6544_/A VGND VGND VPWR VPWR _6414_/Y sky130_fd_sc_hd__inv_2
X_7394_ _7398_/CLK _7394_/D _6674_/Y VGND VGND VPWR VPWR _7394_/Q sky130_fd_sc_hd__dfrtp_2
XFILLER_115_430 VGND VGND VPWR VPWR sky130_fd_sc_hd__decap_3
X_3557_ _7221_/Q _3377_/X _5229_/C _7125_/Q _3556_/X VGND VGND VPWR VPWR _3557_/X
+ sky130_fd_sc_hd__a221o_2
X_6345_ _6672_/A VGND VGND VPWR VPWR _6345_/Y sky130_fd_sc_hd__inv_2
XTAP_TAPCELL_ROW_112_1717 VGND VPWR sky130_fd_sc_hd__tapvpwrvgnd_1
XFILLER_115_452 VGND VGND VPWR VPWR sky130_fd_sc_hd__decap_3
XTAP_TAPCELL_ROW_112_1728 VGND VPWR sky130_fd_sc_hd__tapvpwrvgnd_1
XFILLER_103_603 VGND VGND VPWR VPWR sky130_fd_sc_hd__decap_3
X_6276_ _6278_/A VGND VGND VPWR VPWR _6276_/Y sky130_fd_sc_hd__inv_2
X_3488_ _7279_/Q _3488_/B VGND VGND VPWR VPWR _3488_/X sky130_fd_sc_hd__and2_2
XFILLER_103_647 VGND VGND VPWR VPWR sky130_fd_sc_hd__decap_3
XFILLER_88_347 VGND VGND VPWR VPWR sky130_fd_sc_hd__decap_3
X_5227_ _7215_/Q _5223_/B _5655_/B VGND VGND VPWR VPWR _7215_/D sky130_fd_sc_hd__a21o_2
XFILLER_102_135 VGND VGND VPWR VPWR sky130_fd_sc_hd__fill_2
XFILLER_57_712 VGND VGND VPWR VPWR sky130_fd_sc_hd__decap_3
XTAP_TAPCELL_ROW_71_1193 VGND VPWR sky130_fd_sc_hd__tapvpwrvgnd_1
XFILLER_56_200 VGND VGND VPWR VPWR sky130_fd_sc_hd__decap_3
XPHY_EDGE_ROW_16_Left_140 VGND VGND VPWR VPWR sky130_fd_sc_hd__decap_3
XFILLER_84_531 VGND VGND VPWR VPWR sky130_fd_sc_hd__fill_1
XFILLER_111_691 VGND VGND VPWR VPWR sky130_fd_sc_hd__decap_3
XFILLER_29_447 VGND VGND VPWR VPWR sky130_fd_sc_hd__fill_1
X_4109_ _4376_/A _4141_/A _4141_/B _4142_/C VGND VGND VPWR VPWR _4109_/X sky130_fd_sc_hd__o31a_2
XFILLER_110_190 VGND VGND VPWR VPWR sky130_fd_sc_hd__decap_3
XFILLER_72_704 VGND VGND VPWR VPWR sky130_fd_sc_hd__decap_3
XFILLER_17_609 VGND VGND VPWR VPWR sky130_fd_sc_hd__decap_3
X_5089_ _3521_/Y _4315_/A _5086_/A _5101_/A _5088_/X VGND VGND VPWR VPWR _5089_/Y
+ sky130_fd_sc_hd__o221ai_2
XFILLER_84_575 VGND VGND VPWR VPWR sky130_fd_sc_hd__decap_3
XFILLER_112_11 VGND VGND VPWR VPWR sky130_fd_sc_hd__decap_3
XFILLER_56_277 VGND VGND VPWR VPWR sky130_fd_sc_hd__fill_2
XTAP_TAPCELL_ROW_27_615 VGND VPWR sky130_fd_sc_hd__tapvpwrvgnd_1
XFILLER_44_439 VGND VGND VPWR VPWR sky130_fd_sc_hd__decap_3
XFILLER_71_225 VGND VGND VPWR VPWR sky130_fd_sc_hd__fill_2
XFILLER_25_620 VGND VGND VPWR VPWR sky130_fd_sc_hd__decap_3
XFILLER_112_44 VGND VGND VPWR VPWR sky130_fd_sc_hd__decap_3
XFILLER_37_491 VGND VGND VPWR VPWR sky130_fd_sc_hd__decap_3
XFILLER_25_653 VGND VGND VPWR VPWR sky130_fd_sc_hd__decap_3
XTAP_TAPCELL_ROW_55_979 VGND VPWR sky130_fd_sc_hd__tapvpwrvgnd_1
XFILLER_72_26 VGND VGND VPWR VPWR sky130_fd_sc_hd__fill_2
XFILLER_24_130 VGND VGND VPWR VPWR sky130_fd_sc_hd__decap_3
XTAP_TAPCELL_ROW_123_1868 VGND VPWR sky130_fd_sc_hd__tapvpwrvgnd_1
XFILLER_24_141 VGND VGND VPWR VPWR sky130_fd_sc_hd__decap_3
XFILLER_112_88 VGND VGND VPWR VPWR sky130_fd_sc_hd__fill_1
XFILLER_52_461 VGND VGND VPWR VPWR sky130_fd_sc_hd__decap_3
XFILLER_40_601 VGND VGND VPWR VPWR sky130_fd_sc_hd__decap_3
XTAP_TAPCELL_ROW_123_1879 VGND VPWR sky130_fd_sc_hd__tapvpwrvgnd_1
XFILLER_25_697 VGND VGND VPWR VPWR sky130_fd_sc_hd__decap_3
XFILLER_52_483 VGND VGND VPWR VPWR sky130_fd_sc_hd__decap_3
XFILLER_24_174 VGND VGND VPWR VPWR sky130_fd_sc_hd__decap_3
XFILLER_40_634 VGND VGND VPWR VPWR sky130_fd_sc_hd__decap_3
XFILLER_12_325 VGND VGND VPWR VPWR sky130_fd_sc_hd__decap_3
XFILLER_40_645 VGND VGND VPWR VPWR sky130_fd_sc_hd__decap_3
XFILLER_12_358 VGND VGND VPWR VPWR sky130_fd_sc_hd__decap_3
XFILLER_8_307 VGND VGND VPWR VPWR sky130_fd_sc_hd__fill_1
XFILLER_40_678 VGND VGND VPWR VPWR sky130_fd_sc_hd__decap_3
XFILLER_21_30 VGND VGND VPWR VPWR sky130_fd_sc_hd__decap_3
XFILLER_21_63 VGND VGND VPWR VPWR sky130_fd_sc_hd__fill_2
XFILLER_4_557 VGND VGND VPWR VPWR sky130_fd_sc_hd__decap_3
XFILLER_121_455 VGND VGND VPWR VPWR sky130_fd_sc_hd__decap_3
XTAP_TAPCELL_ROW_7_362 VGND VPWR sky130_fd_sc_hd__tapvpwrvgnd_1
XFILLER_94_306 VGND VGND VPWR VPWR sky130_fd_sc_hd__fill_2
XFILLER_48_701 VGND VGND VPWR VPWR sky130_fd_sc_hd__decap_3
XFILLER_121_488 VGND VGND VPWR VPWR sky130_fd_sc_hd__decap_3
XTAP_TAPCELL_ROW_89_1421 VGND VPWR sky130_fd_sc_hd__tapvpwrvgnd_1
XFILLER_75_520 VGND VGND VPWR VPWR sky130_fd_sc_hd__decap_3
XFILLER_48_734 VGND VGND VPWR VPWR sky130_fd_sc_hd__fill_1
XFILLER_47_211 VGND VGND VPWR VPWR sky130_fd_sc_hd__decap_3
XFILLER_87_391 VGND VGND VPWR VPWR sky130_fd_sc_hd__fill_1
XFILLER_47_222 VGND VGND VPWR VPWR sky130_fd_sc_hd__fill_2
XFILLER_75_542 VGND VGND VPWR VPWR sky130_fd_sc_hd__decap_3
XFILLER_63_715 VGND VGND VPWR VPWR sky130_fd_sc_hd__decap_3
XFILLER_62_203 VGND VGND VPWR VPWR sky130_fd_sc_hd__decap_3
XFILLER_75_597 VGND VGND VPWR VPWR sky130_fd_sc_hd__decap_3
XFILLER_62_214 VGND VGND VPWR VPWR sky130_fd_sc_hd__decap_3
XFILLER_46_71 VGND VGND VPWR VPWR sky130_fd_sc_hd__decap_3
XFILLER_28_480 VGND VGND VPWR VPWR sky130_fd_sc_hd__decap_3
XFILLER_16_631 VGND VGND VPWR VPWR sky130_fd_sc_hd__decap_3
XFILLER_90_578 VGND VGND VPWR VPWR sky130_fd_sc_hd__decap_3
XFILLER_90_589 VGND VGND VPWR VPWR sky130_fd_sc_hd__decap_3
XFILLER_16_675 VGND VGND VPWR VPWR sky130_fd_sc_hd__decap_3
XFILLER_43_461 VGND VGND VPWR VPWR sky130_fd_sc_hd__decap_3
XFILLER_31_612 VGND VGND VPWR VPWR sky130_fd_sc_hd__decap_3
XFILLER_15_163 VGND VGND VPWR VPWR sky130_fd_sc_hd__decap_3
XFILLER_43_483 VGND VGND VPWR VPWR sky130_fd_sc_hd__decap_3
XFILLER_31_623 VGND VGND VPWR VPWR sky130_fd_sc_hd__decap_3
XFILLER_31_656 VGND VGND VPWR VPWR sky130_fd_sc_hd__decap_3
XFILLER_87_6 VGND VGND VPWR VPWR sky130_fd_sc_hd__decap_3
XFILLER_117_706 VGND VGND VPWR VPWR sky130_fd_sc_hd__decap_3
XFILLER_7_340 VGND VGND VPWR VPWR sky130_fd_sc_hd__fill_1
X_4460_ _4460_/A _4460_/B VGND VGND VPWR VPWR _4460_/Y sky130_fd_sc_hd__nand2_2
XFILLER_116_249 VGND VGND VPWR VPWR sky130_fd_sc_hd__decap_3
XFILLER_109_290 VGND VGND VPWR VPWR sky130_fd_sc_hd__fill_2
X_4391_ _7401_/Q _4399_/A2 _4436_/B1 _7177_/Q _4390_/X VGND VGND VPWR VPWR _4391_/X
+ sky130_fd_sc_hd__a221o_2
XFILLER_98_601 VGND VGND VPWR VPWR sky130_fd_sc_hd__decap_3
X_3342_ _3561_/B _3386_/A VGND VGND VPWR VPWR _5118_/D sky130_fd_sc_hd__nand2b_4
XFILLER_98_634 VGND VGND VPWR VPWR sky130_fd_sc_hd__decap_3
XFILLER_112_411 VGND VGND VPWR VPWR sky130_fd_sc_hd__decap_3
XFILLER_98_645 VGND VGND VPWR VPWR sky130_fd_sc_hd__decap_3
XFILLER_112_433 VGND VGND VPWR VPWR sky130_fd_sc_hd__decap_3
XFILLER_97_144 VGND VGND VPWR VPWR sky130_fd_sc_hd__decap_3
XFILLER_58_509 VGND VGND VPWR VPWR sky130_fd_sc_hd__decap_3
XFILLER_98_678 VGND VGND VPWR VPWR sky130_fd_sc_hd__decap_3
XFILLER_97_166 VGND VGND VPWR VPWR sky130_fd_sc_hd__fill_2
XFILLER_85_317 VGND VGND VPWR VPWR sky130_fd_sc_hd__decap_3
XFILLER_112_477 VGND VGND VPWR VPWR sky130_fd_sc_hd__decap_3
X_5012_ _5012_/A0 _5011_/X _5028_/S VGND VGND VPWR VPWR _7261_/D sky130_fd_sc_hd__mux2_2
Xhold1007 _7205_/Q VGND VGND VPWR VPWR _5249_/A0 sky130_fd_sc_hd__dlygate4sd3_1
XFILLER_39_712 VGND VGND VPWR VPWR sky130_fd_sc_hd__decap_3
XFILLER_100_628 VGND VGND VPWR VPWR sky130_fd_sc_hd__decap_3
Xhold1018 _7204_/Q VGND VGND VPWR VPWR _5251_/A0 sky130_fd_sc_hd__dlygate4sd3_1
XFILLER_38_200 VGND VGND VPWR VPWR sky130_fd_sc_hd__decap_3
Xhold1029 _7385_/Q VGND VGND VPWR VPWR _3864_/A0 sky130_fd_sc_hd__dlygate4sd3_1
XFILLER_78_380 VGND VGND VPWR VPWR sky130_fd_sc_hd__decap_3
XFILLER_66_553 VGND VGND VPWR VPWR sky130_fd_sc_hd__decap_3
XFILLER_54_704 VGND VGND VPWR VPWR sky130_fd_sc_hd__decap_3
XFILLER_26_406 VGND VGND VPWR VPWR sky130_fd_sc_hd__decap_3
XFILLER_93_361 VGND VGND VPWR VPWR sky130_fd_sc_hd__decap_3
XFILLER_38_277 VGND VGND VPWR VPWR sky130_fd_sc_hd__decap_3
XFILLER_66_597 VGND VGND VPWR VPWR sky130_fd_sc_hd__decap_3
XFILLER_53_214 VGND VGND VPWR VPWR sky130_fd_sc_hd__decap_3
XFILLER_53_225 VGND VGND VPWR VPWR sky130_fd_sc_hd__decap_3
X_6963_ clkload4/A _6963_/D VGND VGND VPWR VPWR _6963_/Q sky130_fd_sc_hd__dfxtp_2
XTAP_TAPCELL_ROW_109_1690 VGND VPWR sky130_fd_sc_hd__tapvpwrvgnd_1
XFILLER_81_567 VGND VGND VPWR VPWR sky130_fd_sc_hd__decap_3
X_6894_ _6942_/CLK _6894_/D VGND VGND VPWR VPWR _6894_/Q sky130_fd_sc_hd__dfxtp_2
XFILLER_22_601 VGND VGND VPWR VPWR sky130_fd_sc_hd__decap_3
XTAP_TAPCELL_ROW_52_938 VGND VPWR sky130_fd_sc_hd__tapvpwrvgnd_1
XFILLER_34_472 VGND VGND VPWR VPWR sky130_fd_sc_hd__decap_3
XFILLER_34_483 VGND VGND VPWR VPWR sky130_fd_sc_hd__fill_1
XTAP_TAPCELL_ROW_52_949 VGND VPWR sky130_fd_sc_hd__tapvpwrvgnd_1
XFILLER_22_634 VGND VGND VPWR VPWR sky130_fd_sc_hd__decap_3
XFILLER_22_645 VGND VGND VPWR VPWR sky130_fd_sc_hd__decap_3
XFILLER_22_678 VGND VGND VPWR VPWR sky130_fd_sc_hd__decap_3
XTAP_TAPCELL_ROW_32_684 VGND VPWR sky130_fd_sc_hd__tapvpwrvgnd_1
XFILLER_21_199 VGND VGND VPWR VPWR sky130_fd_sc_hd__decap_3
X_4727_ _7007_/Q _4750_/B _5015_/A VGND VGND VPWR VPWR _4728_/B sky130_fd_sc_hd__o21a_2
XFILLER_108_728 VGND VGND VPWR VPWR sky130_fd_sc_hd__decap_3
X_4658_ _4658_/A _4658_/B VGND VGND VPWR VPWR _4658_/Y sky130_fd_sc_hd__nand2_2
XFILLER_107_249 VGND VGND VPWR VPWR sky130_fd_sc_hd__decap_3
X_3609_ _5071_/A _5072_/A VGND VGND VPWR VPWR _3610_/B sky130_fd_sc_hd__nand2_2
Xhold830 _6891_/Q VGND VGND VPWR VPWR _6891_/D sky130_fd_sc_hd__dlygate4sd3_1
Xhold841 _7076_/Q VGND VGND VPWR VPWR _7076_/D sky130_fd_sc_hd__dlygate4sd3_1
X_7377_ _7380_/CLK _7377_/D _6657_/Y VGND VGND VPWR VPWR _7377_/Q sky130_fd_sc_hd__dfrtp_2
XTAP_TAPCELL_ROW_73_1211 VGND VPWR sky130_fd_sc_hd__tapvpwrvgnd_1
X_4589_ _4589_/A _4595_/B VGND VGND VPWR VPWR _7286_/D sky130_fd_sc_hd__and2_2
Xhold852 _7074_/Q VGND VGND VPWR VPWR _7074_/D sky130_fd_sc_hd__dlygate4sd3_1
XFILLER_1_505 VGND VGND VPWR VPWR sky130_fd_sc_hd__decap_3
XTAP_TAPCELL_ROW_73_1222 VGND VPWR sky130_fd_sc_hd__tapvpwrvgnd_1
Xmax_cap571 _6520_/A VGND VGND VPWR VPWR _6581_/A sky130_fd_sc_hd__buf_2
XFILLER_89_612 VGND VGND VPWR VPWR sky130_fd_sc_hd__decap_3
Xhold863 _7092_/Q VGND VGND VPWR VPWR _7092_/D sky130_fd_sc_hd__dlygate4sd3_1
XFILLER_89_623 VGND VGND VPWR VPWR sky130_fd_sc_hd__decap_3
XFILLER_88_100 VGND VGND VPWR VPWR sky130_fd_sc_hd__fill_2
XFILLER_107_22 VGND VGND VPWR VPWR sky130_fd_sc_hd__decap_3
X_6328_ _6680_/A VGND VGND VPWR VPWR _6328_/Y sky130_fd_sc_hd__inv_2
Xhold874 _7086_/Q VGND VGND VPWR VPWR _7086_/D sky130_fd_sc_hd__dlygate4sd3_1
Xhold885 _7078_/Q VGND VGND VPWR VPWR _7078_/D sky130_fd_sc_hd__dlygate4sd3_1
XFILLER_1_538 VGND VGND VPWR VPWR sky130_fd_sc_hd__decap_3
Xhold896 _7100_/Q VGND VGND VPWR VPWR _7100_/D sky130_fd_sc_hd__dlygate4sd3_1
XFILLER_107_55 VGND VGND VPWR VPWR sky130_fd_sc_hd__fill_1
XFILLER_89_656 VGND VGND VPWR VPWR sky130_fd_sc_hd__decap_3
XFILLER_88_133 VGND VGND VPWR VPWR sky130_fd_sc_hd__decap_3
XFILLER_88_144 VGND VGND VPWR VPWR sky130_fd_sc_hd__fill_2
XFILLER_67_15 VGND VGND VPWR VPWR sky130_fd_sc_hd__decap_3
XFILLER_103_455 VGND VGND VPWR VPWR sky130_fd_sc_hd__decap_3
X_6259_ _6350_/A VGND VGND VPWR VPWR _6259_/Y sky130_fd_sc_hd__inv_2
XFILLER_67_48 VGND VGND VPWR VPWR sky130_fd_sc_hd__decap_3
XTAP_TAPCELL_ROW_4_321 VGND VPWR sky130_fd_sc_hd__tapvpwrvgnd_1
XFILLER_57_531 VGND VGND VPWR VPWR sky130_fd_sc_hd__fill_2
XFILLER_29_244 VGND VGND VPWR VPWR sky130_fd_sc_hd__decap_3
XFILLER_123_32 VGND VGND VPWR VPWR sky130_fd_sc_hd__decap_3
XFILLER_45_715 VGND VGND VPWR VPWR sky130_fd_sc_hd__decap_3
XFILLER_17_417 VGND VGND VPWR VPWR sky130_fd_sc_hd__fill_2
XFILLER_83_36 VGND VGND VPWR VPWR sky130_fd_sc_hd__decap_3
XFILLER_84_394 VGND VGND VPWR VPWR sky130_fd_sc_hd__decap_3
XFILLER_72_545 VGND VGND VPWR VPWR sky130_fd_sc_hd__decap_3
XFILLER_60_707 VGND VGND VPWR VPWR sky130_fd_sc_hd__decap_3
XTAP_TAPCELL_ROW_84_1362 VGND VPWR sky130_fd_sc_hd__tapvpwrvgnd_1
XFILLER_72_589 VGND VGND VPWR VPWR sky130_fd_sc_hd__decap_3
XFILLER_13_612 VGND VGND VPWR VPWR sky130_fd_sc_hd__decap_3
XFILLER_13_623 VGND VGND VPWR VPWR sky130_fd_sc_hd__decap_3
XPHY_EDGE_ROW_11_Right_11 VGND VGND VPWR VPWR sky130_fd_sc_hd__decap_3
XFILLER_13_656 VGND VGND VPWR VPWR sky130_fd_sc_hd__decap_3
XFILLER_40_453 VGND VGND VPWR VPWR sky130_fd_sc_hd__decap_3
XFILLER_12_144 VGND VGND VPWR VPWR sky130_fd_sc_hd__fill_1
XFILLER_9_638 VGND VGND VPWR VPWR sky130_fd_sc_hd__decap_3
XFILLER_40_486 VGND VGND VPWR VPWR sky130_fd_sc_hd__decap_3
XFILLER_12_177 VGND VGND VPWR VPWR sky130_fd_sc_hd__decap_3
XFILLER_4_321 VGND VGND VPWR VPWR sky130_fd_sc_hd__decap_3
XFILLER_99_409 VGND VGND VPWR VPWR sky130_fd_sc_hd__decap_3
XPHY_EDGE_ROW_20_Right_20 VGND VGND VPWR VPWR sky130_fd_sc_hd__decap_3
XFILLER_106_271 VGND VGND VPWR VPWR sky130_fd_sc_hd__decap_3
XFILLER_79_122 VGND VGND VPWR VPWR sky130_fd_sc_hd__decap_3
XFILLER_121_241 VGND VGND VPWR VPWR sky130_fd_sc_hd__fill_1
XFILLER_95_615 VGND VGND VPWR VPWR sky130_fd_sc_hd__fill_1
XFILLER_95_626 VGND VGND VPWR VPWR sky130_fd_sc_hd__decap_3
XFILLER_67_328 VGND VGND VPWR VPWR sky130_fd_sc_hd__fill_2
XFILLER_95_659 VGND VGND VPWR VPWR sky130_fd_sc_hd__decap_3
XFILLER_94_147 VGND VGND VPWR VPWR sky130_fd_sc_hd__fill_1
XFILLER_82_309 VGND VGND VPWR VPWR sky130_fd_sc_hd__decap_3
XFILLER_57_81 VGND VGND VPWR VPWR sky130_fd_sc_hd__fill_2
XFILLER_48_564 VGND VGND VPWR VPWR sky130_fd_sc_hd__decap_3
XFILLER_36_704 VGND VGND VPWR VPWR sky130_fd_sc_hd__decap_3
XFILLER_75_372 VGND VGND VPWR VPWR sky130_fd_sc_hd__decap_3
XFILLER_35_225 VGND VGND VPWR VPWR sky130_fd_sc_hd__decap_3
XFILLER_90_342 VGND VGND VPWR VPWR sky130_fd_sc_hd__decap_3
XFILLER_35_258 VGND VGND VPWR VPWR sky130_fd_sc_hd__decap_3
XFILLER_63_567 VGND VGND VPWR VPWR sky130_fd_sc_hd__decap_3
XFILLER_51_718 VGND VGND VPWR VPWR sky130_fd_sc_hd__decap_3
XFILLER_23_409 VGND VGND VPWR VPWR sky130_fd_sc_hd__decap_3
X_3960_ _7360_/Q _4503_/A0 _3964_/S VGND VGND VPWR VPWR _7360_/D sky130_fd_sc_hd__mux2_2
XFILLER_51_729 VGND VGND VPWR VPWR sky130_fd_sc_hd__decap_3
XFILLER_50_206 VGND VGND VPWR VPWR sky130_fd_sc_hd__decap_3
XFILLER_90_386 VGND VGND VPWR VPWR sky130_fd_sc_hd__fill_2
X_3891_ _6951_/Q _3891_/A2 _3891_/B1 _6957_/Q _3890_/X VGND VGND VPWR VPWR _3891_/X
+ sky130_fd_sc_hd__a221o_2
X_5630_ _5630_/A _5634_/B VGND VGND VPWR VPWR _7013_/D sky130_fd_sc_hd__and2_2
XFILLER_85_3 VGND VGND VPWR VPWR sky130_fd_sc_hd__decap_3
X_5561_ hold966/X _4983_/A _4695_/X VGND VGND VPWR VPWR _7054_/D sky130_fd_sc_hd__o21a_2
XFILLER_8_660 VGND VGND VPWR VPWR sky130_fd_sc_hd__decap_3
XFILLER_117_503 VGND VGND VPWR VPWR sky130_fd_sc_hd__fill_1
X_7300_ _7359_/CLK _7300_/D _6580_/Y VGND VGND VPWR VPWR _7300_/Q sky130_fd_sc_hd__dfrtp_2
XFILLER_117_514 VGND VGND VPWR VPWR sky130_fd_sc_hd__decap_3
XFILLER_8_693 VGND VGND VPWR VPWR sky130_fd_sc_hd__decap_3
XFILLER_117_547 VGND VGND VPWR VPWR sky130_fd_sc_hd__decap_3
XFILLER_7_181 VGND VGND VPWR VPWR sky130_fd_sc_hd__decap_3
X_7231_ _7360_/CLK _7231_/D _6511_/Y VGND VGND VPWR VPWR _7231_/Q sky130_fd_sc_hd__dfrtp_2
XFILLER_105_709 VGND VGND VPWR VPWR sky130_fd_sc_hd__decap_3
X_4443_ _4778_/A _4778_/B _4647_/C _4787_/A _4779_/A VGND VGND VPWR VPWR _4761_/B
+ sky130_fd_sc_hd__a2111o_2
X_4374_ _4371_/Y _4224_/C _4373_/Y VGND VGND VPWR VPWR _4374_/X sky130_fd_sc_hd__o21a_2
X_7162_ _7354_/CLK _7162_/D _6442_/Y VGND VGND VPWR VPWR _7162_/Q sky130_fd_sc_hd__dfrtp_2
XFILLER_98_442 VGND VGND VPWR VPWR sky130_fd_sc_hd__decap_3
X_3325_ _3323_/X _3324_/X _5670_/A VGND VGND VPWR VPWR _3326_/B sky130_fd_sc_hd__a21oi_2
XFILLER_112_230 VGND VGND VPWR VPWR sky130_fd_sc_hd__decap_3
X_7093_ _7318_/CLK _7093_/D _6373_/Y VGND VGND VPWR VPWR _7093_/Q sky130_fd_sc_hd__dfrtp_2
XFILLER_86_604 VGND VGND VPWR VPWR sky130_fd_sc_hd__decap_3
XFILLER_98_475 VGND VGND VPWR VPWR sky130_fd_sc_hd__fill_1
XFILLER_86_637 VGND VGND VPWR VPWR sky130_fd_sc_hd__decap_3
XFILLER_85_103 VGND VGND VPWR VPWR sky130_fd_sc_hd__decap_3
XFILLER_112_274 VGND VGND VPWR VPWR sky130_fd_sc_hd__decap_3
XFILLER_100_414 VGND VGND VPWR VPWR sky130_fd_sc_hd__decap_3
XFILLER_86_648 VGND VGND VPWR VPWR sky130_fd_sc_hd__decap_3
XFILLER_112_296 VGND VGND VPWR VPWR sky130_fd_sc_hd__decap_3
XFILLER_85_158 VGND VGND VPWR VPWR sky130_fd_sc_hd__decap_3
XFILLER_39_553 VGND VGND VPWR VPWR sky130_fd_sc_hd__decap_3
XFILLER_85_169 VGND VGND VPWR VPWR sky130_fd_sc_hd__decap_3
XFILLER_39_564 VGND VGND VPWR VPWR sky130_fd_sc_hd__fill_1
XFILLER_27_715 VGND VGND VPWR VPWR sky130_fd_sc_hd__decap_3
XFILLER_94_681 VGND VGND VPWR VPWR sky130_fd_sc_hd__decap_3
XFILLER_26_214 VGND VGND VPWR VPWR sky130_fd_sc_hd__decap_3
XFILLER_54_545 VGND VGND VPWR VPWR sky130_fd_sc_hd__decap_3
XTAP_TAPCELL_ROW_37_743 VGND VPWR sky130_fd_sc_hd__tapvpwrvgnd_1
XFILLER_93_191 VGND VGND VPWR VPWR sky130_fd_sc_hd__decap_3
XTAP_TAPCELL_ROW_37_754 VGND VPWR sky130_fd_sc_hd__tapvpwrvgnd_1
XFILLER_42_707 VGND VGND VPWR VPWR sky130_fd_sc_hd__decap_3
XFILLER_54_578 VGND VGND VPWR VPWR sky130_fd_sc_hd__decap_3
X_6946_ _7380_/CLK _6946_/D VGND VGND VPWR VPWR _6946_/Q sky130_fd_sc_hd__dfxtp_2
XFILLER_54_589 VGND VGND VPWR VPWR sky130_fd_sc_hd__fill_1
XFILLER_53_28 VGND VGND VPWR VPWR sky130_fd_sc_hd__decap_3
XFILLER_41_228 VGND VGND VPWR VPWR sky130_fd_sc_hd__decap_3
XTAP_TAPCELL_ROW_120_1827 VGND VPWR sky130_fd_sc_hd__tapvpwrvgnd_1
X_6877_ _7380_/CLK _6877_/D VGND VGND VPWR VPWR _6877_/Q sky130_fd_sc_hd__dfxtp_2
XFILLER_34_291 VGND VGND VPWR VPWR sky130_fd_sc_hd__decap_3
XFILLER_10_604 VGND VGND VPWR VPWR sky130_fd_sc_hd__decap_3
XFILLER_22_464 VGND VGND VPWR VPWR sky130_fd_sc_hd__decap_3
XFILLER_22_486 VGND VGND VPWR VPWR sky130_fd_sc_hd__decap_3
XFILLER_10_637 VGND VGND VPWR VPWR sky130_fd_sc_hd__decap_3
XFILLER_10_648 VGND VGND VPWR VPWR sky130_fd_sc_hd__decap_3
XFILLER_6_619 VGND VGND VPWR VPWR sky130_fd_sc_hd__decap_3
XFILLER_108_536 VGND VGND VPWR VPWR sky130_fd_sc_hd__decap_3
XFILLER_118_21 VGND VGND VPWR VPWR sky130_fd_sc_hd__decap_3
XFILLER_118_32 VGND VGND VPWR VPWR sky130_fd_sc_hd__decap_3
XFILLER_108_569 VGND VGND VPWR VPWR sky130_fd_sc_hd__decap_3
XFILLER_118_65 VGND VGND VPWR VPWR sky130_fd_sc_hd__decap_3
XFILLER_123_539 VGND VGND VPWR VPWR sky130_fd_sc_hd__decap_3
Xhold660 _6780_/Q VGND VGND VPWR VPWR _6780_/D sky130_fd_sc_hd__dlygate4sd3_1
Xhold671 _6773_/Q VGND VGND VPWR VPWR _6773_/D sky130_fd_sc_hd__dlygate4sd3_1
XFILLER_104_731 VGND VGND VPWR VPWR sky130_fd_sc_hd__decap_3
Xhold682 _6961_/Q VGND VGND VPWR VPWR _6961_/D sky130_fd_sc_hd__dlygate4sd3_1
XFILLER_89_442 VGND VGND VPWR VPWR sky130_fd_sc_hd__decap_3
Xhold693 _6765_/Q VGND VGND VPWR VPWR _6765_/D sky130_fd_sc_hd__dlygate4sd3_1
XFILLER_78_69 VGND VGND VPWR VPWR sky130_fd_sc_hd__decap_3
XFILLER_89_464 VGND VGND VPWR VPWR sky130_fd_sc_hd__decap_3
XFILLER_77_615 VGND VGND VPWR VPWR sky130_fd_sc_hd__fill_1
XFILLER_77_626 VGND VGND VPWR VPWR sky130_fd_sc_hd__decap_3
XFILLER_49_317 VGND VGND VPWR VPWR sky130_fd_sc_hd__decap_3
XFILLER_76_125 VGND VGND VPWR VPWR sky130_fd_sc_hd__decap_3
XFILLER_77_659 VGND VGND VPWR VPWR sky130_fd_sc_hd__decap_3
XFILLER_103_296 VGND VGND VPWR VPWR sky130_fd_sc_hd__decap_3
XFILLER_92_607 VGND VGND VPWR VPWR sky130_fd_sc_hd__decap_3
XFILLER_18_704 VGND VGND VPWR VPWR sky130_fd_sc_hd__decap_3
XFILLER_91_106 VGND VGND VPWR VPWR sky130_fd_sc_hd__decap_3
XFILLER_57_361 VGND VGND VPWR VPWR sky130_fd_sc_hd__decap_3
XFILLER_91_128 VGND VGND VPWR VPWR sky130_fd_sc_hd__decap_3
XFILLER_57_383 VGND VGND VPWR VPWR sky130_fd_sc_hd__decap_3
XFILLER_17_225 VGND VGND VPWR VPWR sky130_fd_sc_hd__decap_3
XFILLER_33_718 VGND VGND VPWR VPWR sky130_fd_sc_hd__decap_3
XFILLER_60_504 VGND VGND VPWR VPWR sky130_fd_sc_hd__decap_3
XFILLER_33_729 VGND VGND VPWR VPWR sky130_fd_sc_hd__decap_3
XFILLER_60_526 VGND VGND VPWR VPWR sky130_fd_sc_hd__decap_3
XFILLER_32_228 VGND VGND VPWR VPWR sky130_fd_sc_hd__decap_3
XFILLER_13_442 VGND VGND VPWR VPWR sky130_fd_sc_hd__decap_3
XTAP_TAPCELL_ROW_15_459 VGND VPWR sky130_fd_sc_hd__tapvpwrvgnd_1
XFILLER_9_402 VGND VGND VPWR VPWR sky130_fd_sc_hd__decap_3
XFILLER_9_446 VGND VGND VPWR VPWR sky130_fd_sc_hd__fill_2
XFILLER_40_294 VGND VGND VPWR VPWR sky130_fd_sc_hd__fill_1
XFILLER_71_9 VGND VGND VPWR VPWR sky130_fd_sc_hd__decap_3
XTAP_TAPCELL_ROW_97_1531 VGND VPWR sky130_fd_sc_hd__tapvpwrvgnd_1
XFILLER_5_641 VGND VGND VPWR VPWR sky130_fd_sc_hd__decap_3
XFILLER_114_517 VGND VGND VPWR VPWR sky130_fd_sc_hd__decap_3
XFILLER_99_228 VGND VGND VPWR VPWR sky130_fd_sc_hd__decap_3
XFILLER_5_685 VGND VGND VPWR VPWR sky130_fd_sc_hd__decap_3
XFILLER_4_11 VGND VGND VPWR VPWR sky130_fd_sc_hd__decap_3
XFILLER_114_539 VGND VGND VPWR VPWR sky130_fd_sc_hd__decap_3
XFILLER_107_591 VGND VGND VPWR VPWR sky130_fd_sc_hd__decap_3
XFILLER_68_604 VGND VGND VPWR VPWR sky130_fd_sc_hd__decap_3
XFILLER_4_66 VGND VGND VPWR VPWR sky130_fd_sc_hd__fill_1
XFILLER_110_701 VGND VGND VPWR VPWR sky130_fd_sc_hd__decap_3
XFILLER_122_572 VGND VGND VPWR VPWR sky130_fd_sc_hd__decap_3
XFILLER_95_423 VGND VGND VPWR VPWR sky130_fd_sc_hd__decap_3
XFILLER_68_637 VGND VGND VPWR VPWR sky130_fd_sc_hd__decap_3
XFILLER_68_648 VGND VGND VPWR VPWR sky130_fd_sc_hd__decap_3
XFILLER_110_734 VGND VGND VPWR VPWR sky130_fd_sc_hd__fill_1
X_4090_ _7302_/Q _4979_/S _4088_/X _4089_/X VGND VGND VPWR VPWR _4090_/X sky130_fd_sc_hd__a211o_2
XFILLER_95_467 VGND VGND VPWR VPWR sky130_fd_sc_hd__decap_3
XFILLER_67_169 VGND VGND VPWR VPWR sky130_fd_sc_hd__decap_3
XFILLER_83_629 VGND VGND VPWR VPWR sky130_fd_sc_hd__decap_3
XFILLER_82_106 VGND VGND VPWR VPWR sky130_fd_sc_hd__fill_2
XFILLER_36_501 VGND VGND VPWR VPWR sky130_fd_sc_hd__fill_2
XFILLER_82_128 VGND VGND VPWR VPWR sky130_fd_sc_hd__decap_3
XFILLER_76_681 VGND VGND VPWR VPWR sky130_fd_sc_hd__decap_3
XFILLER_48_383 VGND VGND VPWR VPWR sky130_fd_sc_hd__fill_2
XFILLER_24_707 VGND VGND VPWR VPWR sky130_fd_sc_hd__decap_3
X_6800_ clkload9/A _6800_/D VGND VGND VPWR VPWR _6800_/Q sky130_fd_sc_hd__dfxtp_2
Xplace320 _5278_/S VGND VGND VPWR VPWR _5258_/S sky130_fd_sc_hd__buf_2
XFILLER_91_662 VGND VGND VPWR VPWR sky130_fd_sc_hd__decap_3
Xplace331 _3429_/X VGND VGND VPWR VPWR _4460_/A sky130_fd_sc_hd__buf_2
XFILLER_91_673 VGND VGND VPWR VPWR sky130_fd_sc_hd__decap_3
XFILLER_63_364 VGND VGND VPWR VPWR sky130_fd_sc_hd__decap_3
XFILLER_51_515 VGND VGND VPWR VPWR sky130_fd_sc_hd__decap_3
XFILLER_36_589 VGND VGND VPWR VPWR sky130_fd_sc_hd__decap_3
XTAP_TAPCELL_ROW_34_713 VGND VPWR sky130_fd_sc_hd__tapvpwrvgnd_1
X_4992_ _4987_/A _4991_/Y _4814_/A VGND VGND VPWR VPWR _4992_/Y sky130_fd_sc_hd__a21oi_2
Xplace342 _3377_/X VGND VGND VPWR VPWR _4349_/B1 sky130_fd_sc_hd__buf_2
Xplace353 _4351_/A2 VGND VGND VPWR VPWR _4434_/A2 sky130_fd_sc_hd__buf_2
Xplace364 _4352_/B1 VGND VGND VPWR VPWR _4267_/B1 sky130_fd_sc_hd__buf_2
X_6731_ clkload9/A _6731_/D VGND VGND VPWR VPWR _6731_/Q sky130_fd_sc_hd__dfxtp_2
Xplace375 _3904_/A VGND VGND VPWR VPWR _3860_/S sky130_fd_sc_hd__buf_2
XFILLER_90_194 VGND VGND VPWR VPWR sky130_fd_sc_hd__fill_2
X_3943_ _7368_/Q _4486_/A0 _3943_/S VGND VGND VPWR VPWR _7368_/D sky130_fd_sc_hd__mux2_2
Xplace386 _3334_/Y VGND VGND VPWR VPWR _3339_/C1 sky130_fd_sc_hd__buf_2
Xplace397 _7412_/A VGND VGND VPWR VPWR _5344_/S sky130_fd_sc_hd__buf_2
X_6662_ _6662_/A VGND VGND VPWR VPWR _6662_/Y sky130_fd_sc_hd__inv_2
X_3874_ _5104_/A _3874_/B VGND VGND VPWR VPWR _3874_/X sky130_fd_sc_hd__or2_2
XFILLER_31_272 VGND VGND VPWR VPWR sky130_fd_sc_hd__fill_1
X_5613_ _5613_/A _5633_/B VGND VGND VPWR VPWR _7021_/D sky130_fd_sc_hd__or2_2
Xclkbuf_3_2__f_clk clkbuf_0_clk/X VGND VGND VPWR VPWR clkbuf_leaf_2_clk/A sky130_fd_sc_hd__clkbuf_16
X_6593_ _6635_/A VGND VGND VPWR VPWR _6593_/Y sky130_fd_sc_hd__inv_2
XFILLER_117_300 VGND VGND VPWR VPWR sky130_fd_sc_hd__decap_3
XFILLER_117_322 VGND VGND VPWR VPWR sky130_fd_sc_hd__decap_3
XTAP_TAPCELL_ROW_57_1003 VGND VPWR sky130_fd_sc_hd__tapvpwrvgnd_1
XTAP_TAPCELL_ROW_57_1014 VGND VPWR sky130_fd_sc_hd__tapvpwrvgnd_1
XFILLER_117_366 VGND VGND VPWR VPWR sky130_fd_sc_hd__fill_1
X_7214_ _7370_/CLK _7214_/D _6494_/Y VGND VGND VPWR VPWR _7214_/Q sky130_fd_sc_hd__dfrtp_2
X_4426_ _4446_/A _4426_/B VGND VGND VPWR VPWR _4813_/A sky130_fd_sc_hd__or2_2
X_7145_ _7405_/CLK _7145_/D _6425_/Y VGND VGND VPWR VPWR _7145_/Q sky130_fd_sc_hd__dfrtp_2
XFILLER_98_250 VGND VGND VPWR VPWR sky130_fd_sc_hd__fill_2
XFILLER_113_550 VGND VGND VPWR VPWR sky130_fd_sc_hd__decap_3
X_4357_ _4352_/X _4356_/X _4327_/A VGND VGND VPWR VPWR _4367_/C sky130_fd_sc_hd__o21ai_2
XFILLER_59_615 VGND VGND VPWR VPWR sky130_fd_sc_hd__fill_1
XFILLER_113_561 VGND VGND VPWR VPWR sky130_fd_sc_hd__decap_3
XFILLER_59_626 VGND VGND VPWR VPWR sky130_fd_sc_hd__decap_3
XFILLER_101_712 VGND VGND VPWR VPWR sky130_fd_sc_hd__decap_3
XFILLER_100_200 VGND VGND VPWR VPWR sky130_fd_sc_hd__decap_3
X_3308_ _3371_/A _6979_/Q VGND VGND VPWR VPWR _5118_/C sky130_fd_sc_hd__nand2_2
XFILLER_113_594 VGND VGND VPWR VPWR sky130_fd_sc_hd__decap_3
X_4288_ _4394_/A _4337_/B _4288_/C _4288_/D VGND VGND VPWR VPWR _4288_/X sky130_fd_sc_hd__or4_4
X_7076_ _7398_/CLK _7076_/D _6356_/Y VGND VGND VPWR VPWR _7076_/Q sky130_fd_sc_hd__dfrtp_2
XFILLER_86_445 VGND VGND VPWR VPWR sky130_fd_sc_hd__decap_3
XFILLER_59_659 VGND VGND VPWR VPWR sky130_fd_sc_hd__decap_3
XFILLER_100_233 VGND VGND VPWR VPWR sky130_fd_sc_hd__decap_3
XFILLER_74_607 VGND VGND VPWR VPWR sky130_fd_sc_hd__decap_3
XFILLER_58_158 VGND VGND VPWR VPWR sky130_fd_sc_hd__decap_3
XFILLER_46_309 VGND VGND VPWR VPWR sky130_fd_sc_hd__fill_2
XFILLER_73_106 VGND VGND VPWR VPWR sky130_fd_sc_hd__decap_3
XFILLER_100_277 VGND VGND VPWR VPWR sky130_fd_sc_hd__decap_3
XFILLER_82_640 VGND VGND VPWR VPWR sky130_fd_sc_hd__decap_3
XFILLER_66_191 VGND VGND VPWR VPWR sky130_fd_sc_hd__decap_3
XFILLER_82_651 VGND VGND VPWR VPWR sky130_fd_sc_hd__decap_3
XFILLER_64_49 VGND VGND VPWR VPWR sky130_fd_sc_hd__decap_3
XFILLER_54_342 VGND VGND VPWR VPWR sky130_fd_sc_hd__decap_3
XTAP_TAPCELL_ROW_68_1154 VGND VPWR sky130_fd_sc_hd__tapvpwrvgnd_1
XFILLER_27_578 VGND VGND VPWR VPWR sky130_fd_sc_hd__decap_3
XFILLER_15_718 VGND VGND VPWR VPWR sky130_fd_sc_hd__decap_3
XFILLER_15_729 VGND VGND VPWR VPWR sky130_fd_sc_hd__decap_3
XFILLER_82_684 VGND VGND VPWR VPWR sky130_fd_sc_hd__decap_3
XFILLER_54_375 VGND VGND VPWR VPWR sky130_fd_sc_hd__decap_3
XFILLER_120_11 VGND VGND VPWR VPWR sky130_fd_sc_hd__decap_3
XFILLER_81_183 VGND VGND VPWR VPWR sky130_fd_sc_hd__decap_3
XTAP_TAPCELL_ROW_81_1321 VGND VPWR sky130_fd_sc_hd__tapvpwrvgnd_1
X_6929_ clkload8/A _6929_/D VGND VGND VPWR VPWR _6929_/Q sky130_fd_sc_hd__dfxtp_2
XFILLER_120_44 VGND VGND VPWR VPWR sky130_fd_sc_hd__decap_3
Xfanout21 _6662_/A VGND VGND VPWR VPWR _6672_/A sky130_fd_sc_hd__buf_2
Xfanout32 _6603_/A VGND VGND VPWR VPWR _6566_/A sky130_fd_sc_hd__buf_2
Xfanout43 fanout46/X VGND VGND VPWR VPWR _6644_/A sky130_fd_sc_hd__clkdlybuf4s25_1
XFILLER_120_77 VGND VGND VPWR VPWR sky130_fd_sc_hd__decap_3
Xfanout54 _6646_/A VGND VGND VPWR VPWR _6642_/A sky130_fd_sc_hd__buf_2
XFILLER_22_250 VGND VGND VPWR VPWR sky130_fd_sc_hd__fill_2
XFILLER_120_88 VGND VGND VPWR VPWR sky130_fd_sc_hd__decap_3
XTAP_TAPCELL_ROW_12_418 VGND VPWR sky130_fd_sc_hd__tapvpwrvgnd_1
Xfanout65 _6616_/A VGND VGND VPWR VPWR _6622_/A sky130_fd_sc_hd__clkdlybuf4s25_1
XTAP_TAPCELL_ROW_12_429 VGND VPWR sky130_fd_sc_hd__tapvpwrvgnd_1
Xfanout76 reset VGND VGND VPWR VPWR _6350_/A sky130_fd_sc_hd__buf_2
XFILLER_50_592 VGND VGND VPWR VPWR sky130_fd_sc_hd__decap_3
XFILLER_22_283 VGND VGND VPWR VPWR sky130_fd_sc_hd__fill_2
XFILLER_10_445 VGND VGND VPWR VPWR sky130_fd_sc_hd__decap_3
XFILLER_13_53 VGND VGND VPWR VPWR sky130_fd_sc_hd__decap_3
XFILLER_10_467 VGND VGND VPWR VPWR sky130_fd_sc_hd__decap_3
XFILLER_6_427 VGND VGND VPWR VPWR sky130_fd_sc_hd__decap_3
XFILLER_13_75 VGND VGND VPWR VPWR sky130_fd_sc_hd__fill_2
XFILLER_6_438 VGND VGND VPWR VPWR sky130_fd_sc_hd__decap_3
XFILLER_13_97 VGND VGND VPWR VPWR sky130_fd_sc_hd__fill_2
XTAP_TAPCELL_ROW_79_1294 VGND VPWR sky130_fd_sc_hd__tapvpwrvgnd_1
XFILLER_89_68 VGND VGND VPWR VPWR sky130_fd_sc_hd__fill_1
XFILLER_89_79 VGND VGND VPWR VPWR sky130_fd_sc_hd__decap_3
XFILLER_2_611 VGND VGND VPWR VPWR sky130_fd_sc_hd__decap_3
XFILLER_108_399 VGND VGND VPWR VPWR sky130_fd_sc_hd__decap_3
XTAP_TAPCELL_ROW_92_1461 VGND VPWR sky130_fd_sc_hd__tapvpwrvgnd_1
XFILLER_2_666 VGND VGND VPWR VPWR sky130_fd_sc_hd__decap_3
XPHY_EDGE_ROW_8_Left_132 VGND VGND VPWR VPWR sky130_fd_sc_hd__decap_3
XFILLER_89_261 VGND VGND VPWR VPWR sky130_fd_sc_hd__decap_3
XFILLER_104_572 VGND VGND VPWR VPWR sky130_fd_sc_hd__decap_3
XFILLER_2_699 VGND VGND VPWR VPWR sky130_fd_sc_hd__fill_1
XFILLER_65_607 VGND VGND VPWR VPWR sky130_fd_sc_hd__decap_3
XFILLER_92_404 VGND VGND VPWR VPWR sky130_fd_sc_hd__decap_3
XFILLER_49_169 VGND VGND VPWR VPWR sky130_fd_sc_hd__decap_3
XFILLER_65_629 VGND VGND VPWR VPWR sky130_fd_sc_hd__decap_3
XFILLER_58_681 VGND VGND VPWR VPWR sky130_fd_sc_hd__decap_3
XFILLER_64_139 VGND VGND VPWR VPWR sky130_fd_sc_hd__fill_1
XFILLER_92_459 VGND VGND VPWR VPWR sky130_fd_sc_hd__decap_3
XFILLER_57_191 VGND VGND VPWR VPWR sky130_fd_sc_hd__decap_3
Xhold1190 _7142_/Q VGND VGND VPWR VPWR _5381_/A0 sky130_fd_sc_hd__dlygate4sd3_1
XFILLER_73_662 VGND VGND VPWR VPWR sky130_fd_sc_hd__decap_3
XFILLER_18_578 VGND VGND VPWR VPWR sky130_fd_sc_hd__decap_3
XFILLER_73_673 VGND VGND VPWR VPWR sky130_fd_sc_hd__decap_3
XFILLER_72_150 VGND VGND VPWR VPWR sky130_fd_sc_hd__decap_3
XFILLER_45_364 VGND VGND VPWR VPWR sky130_fd_sc_hd__fill_2
XFILLER_18_589 VGND VGND VPWR VPWR sky130_fd_sc_hd__decap_3
XFILLER_45_386 VGND VGND VPWR VPWR sky130_fd_sc_hd__decap_3
XFILLER_33_526 VGND VGND VPWR VPWR sky130_fd_sc_hd__fill_1
XFILLER_60_323 VGND VGND VPWR VPWR sky130_fd_sc_hd__decap_3
XFILLER_33_548 VGND VGND VPWR VPWR sky130_fd_sc_hd__decap_3
XFILLER_54_82 VGND VGND VPWR VPWR sky130_fd_sc_hd__fill_2
XFILLER_60_356 VGND VGND VPWR VPWR sky130_fd_sc_hd__decap_3
XFILLER_9_210 VGND VGND VPWR VPWR sky130_fd_sc_hd__decap_3
XFILLER_13_272 VGND VGND VPWR VPWR sky130_fd_sc_hd__decap_3
XFILLER_41_592 VGND VGND VPWR VPWR sky130_fd_sc_hd__decap_3
XFILLER_119_609 VGND VGND VPWR VPWR sky130_fd_sc_hd__decap_3
XFILLER_9_254 VGND VGND VPWR VPWR sky130_fd_sc_hd__decap_3
XFILLER_9_287 VGND VGND VPWR VPWR sky130_fd_sc_hd__decap_3
X_3590_ _4460_/A _3590_/B _3590_/C VGND VGND VPWR VPWR _3620_/C sky130_fd_sc_hd__and3_2
Xclkload13 _7318_/CLK VGND VGND VPWR VPWR clkload13/Y sky130_fd_sc_hd__inv_4
Xclkload24 _7371_/CLK VGND VGND VPWR VPWR clkload24/Y sky130_fd_sc_hd__clkinv_4
Xclkload35 _7368_/CLK VGND VGND VPWR VPWR clkload35/X sky130_fd_sc_hd__clkbuf_1
XFILLER_114_303 VGND VGND VPWR VPWR sky130_fd_sc_hd__decap_3
X_5260_ hold991/X _4964_/X _5278_/S VGND VGND VPWR VPWR _7200_/D sky130_fd_sc_hd__mux2_2
XFILLER_114_336 VGND VGND VPWR VPWR sky130_fd_sc_hd__decap_3
XFILLER_48_3 VGND VGND VPWR VPWR sky130_fd_sc_hd__decap_3
X_4211_ _4633_/A _4143_/X _4206_/X _4384_/A _4210_/X VGND VGND VPWR VPWR _4778_/A
+ sky130_fd_sc_hd__a221oi_2
XFILLER_102_509 VGND VGND VPWR VPWR sky130_fd_sc_hd__fill_2
XFILLER_96_710 VGND VGND VPWR VPWR sky130_fd_sc_hd__decap_3
X_4142_ _4205_/A _4142_/B _4142_/C VGND VGND VPWR VPWR _4142_/X sky130_fd_sc_hd__and3_2
XFILLER_95_231 VGND VGND VPWR VPWR sky130_fd_sc_hd__fill_2
XFILLER_68_445 VGND VGND VPWR VPWR sky130_fd_sc_hd__decap_3
XFILLER_110_542 VGND VGND VPWR VPWR sky130_fd_sc_hd__decap_3
XFILLER_56_607 VGND VGND VPWR VPWR sky130_fd_sc_hd__decap_3
XFILLER_28_309 VGND VGND VPWR VPWR sky130_fd_sc_hd__decap_3
X_4073_ _7275_/Q _4431_/A2 _4070_/X _4072_/X VGND VGND VPWR VPWR _4073_/X sky130_fd_sc_hd__a211o_2
XFILLER_110_575 VGND VGND VPWR VPWR sky130_fd_sc_hd__decap_3
XFILLER_68_489 VGND VGND VPWR VPWR sky130_fd_sc_hd__decap_3
XFILLER_64_640 VGND VGND VPWR VPWR sky130_fd_sc_hd__decap_3
XFILLER_64_651 VGND VGND VPWR VPWR sky130_fd_sc_hd__decap_3
XTAP_TAPCELL_ROW_104_1619 VGND VPWR sky130_fd_sc_hd__tapvpwrvgnd_1
XFILLER_64_684 VGND VGND VPWR VPWR sky130_fd_sc_hd__decap_3
XTAP_TAPCELL_ROW_47_882 VGND VPWR sky130_fd_sc_hd__tapvpwrvgnd_1
XFILLER_91_470 VGND VGND VPWR VPWR sky130_fd_sc_hd__decap_3
XFILLER_63_172 VGND VGND VPWR VPWR sky130_fd_sc_hd__decap_3
XFILLER_51_323 VGND VGND VPWR VPWR sky130_fd_sc_hd__fill_2
X_4975_ _4983_/A _4975_/B VGND VGND VPWR VPWR _4975_/Y sky130_fd_sc_hd__nand2_2
X_6714_ _7371_/CLK _6714_/D VGND VGND VPWR VPWR _6714_/Q sky130_fd_sc_hd__dfxtp_2
X_3926_ _6913_/Q _3926_/A2 _3926_/B1 _6777_/Q _3925_/X VGND VGND VPWR VPWR _3926_/X
+ sky130_fd_sc_hd__a221o_2
XFILLER_20_710 VGND VGND VPWR VPWR sky130_fd_sc_hd__decap_3
XTAP_TAPCELL_ROW_63_1084 VGND VPWR sky130_fd_sc_hd__tapvpwrvgnd_1
XFILLER_32_592 VGND VGND VPWR VPWR sky130_fd_sc_hd__decap_3
X_6645_ _6646_/A VGND VGND VPWR VPWR _6645_/Y sky130_fd_sc_hd__inv_2
Xclkload7 clkload7/A VGND VGND VPWR VPWR clkload7/Y sky130_fd_sc_hd__inv_12
X_3857_ hold948/X _3857_/A2 _3856_/X VGND VGND VPWR VPWR _7387_/D sky130_fd_sc_hd__a21o_2
X_6576_ _6608_/A VGND VGND VPWR VPWR _6576_/Y sky130_fd_sc_hd__inv_2
XFILLER_118_631 VGND VGND VPWR VPWR sky130_fd_sc_hd__decap_3
X_3788_ _3741_/X _3785_/X _3787_/X _3735_/X VGND VGND VPWR VPWR _3788_/X sky130_fd_sc_hd__a22o_2
XFILLER_119_9 VGND VGND VPWR VPWR sky130_fd_sc_hd__decap_3
XFILLER_118_675 VGND VGND VPWR VPWR sky130_fd_sc_hd__decap_3
XFILLER_3_419 VGND VGND VPWR VPWR sky130_fd_sc_hd__decap_3
XTAP_TAPCELL_ROW_115_1759 VGND VPWR sky130_fd_sc_hd__tapvpwrvgnd_1
XFILLER_117_185 VGND VGND VPWR VPWR sky130_fd_sc_hd__decap_3
Xoutput540 _7005_/Q VGND VGND VPWR VPWR pc_out[28] sky130_fd_sc_hd__clkdlybuf4s25_1
XFILLER_1_9 VGND VGND VPWR VPWR sky130_fd_sc_hd__decap_3
Xoutput551 _6986_/Q VGND VGND VPWR VPWR pc_out[9] sky130_fd_sc_hd__clkdlybuf4s25_1
XFILLER_105_358 VGND VGND VPWR VPWR sky130_fd_sc_hd__decap_3
XFILLER_78_209 VGND VGND VPWR VPWR sky130_fd_sc_hd__decap_3
X_4409_ _4425_/A _4409_/B VGND VGND VPWR VPWR _4411_/B sky130_fd_sc_hd__nand2_2
XFILLER_99_570 VGND VGND VPWR VPWR sky130_fd_sc_hd__decap_3
XFILLER_87_721 VGND VGND VPWR VPWR sky130_fd_sc_hd__decap_3
XFILLER_120_317 VGND VGND VPWR VPWR sky130_fd_sc_hd__decap_3
XFILLER_87_732 VGND VGND VPWR VPWR sky130_fd_sc_hd__decap_3
XFILLER_59_423 VGND VGND VPWR VPWR sky130_fd_sc_hd__decap_3
XFILLER_115_22 VGND VGND VPWR VPWR sky130_fd_sc_hd__decap_3
X_7128_ _7325_/CLK _7128_/D _6408_/Y VGND VGND VPWR VPWR _7128_/Q sky130_fd_sc_hd__dfrtp_2
XFILLER_113_380 VGND VGND VPWR VPWR sky130_fd_sc_hd__decap_3
XFILLER_59_445 VGND VGND VPWR VPWR sky130_fd_sc_hd__decap_3
XFILLER_113_391 VGND VGND VPWR VPWR sky130_fd_sc_hd__fill_1
XFILLER_115_55 VGND VGND VPWR VPWR sky130_fd_sc_hd__fill_1
XFILLER_86_242 VGND VGND VPWR VPWR sky130_fd_sc_hd__decap_3
XFILLER_47_607 VGND VGND VPWR VPWR sky130_fd_sc_hd__decap_3
XFILLER_86_253 VGND VGND VPWR VPWR sky130_fd_sc_hd__decap_3
XFILLER_75_15 VGND VGND VPWR VPWR sky130_fd_sc_hd__decap_3
XFILLER_59_467 VGND VGND VPWR VPWR sky130_fd_sc_hd__decap_3
XFILLER_115_66 VGND VGND VPWR VPWR sky130_fd_sc_hd__decap_3
XFILLER_101_564 VGND VGND VPWR VPWR sky130_fd_sc_hd__decap_3
X_7059_ _7279_/CLK _7059_/D _6339_/Y VGND VGND VPWR VPWR _7059_/Q sky130_fd_sc_hd__dfrtp_2
XFILLER_47_629 VGND VGND VPWR VPWR sky130_fd_sc_hd__decap_3
XFILLER_115_99 VGND VGND VPWR VPWR sky130_fd_sc_hd__decap_3
XFILLER_86_286 VGND VGND VPWR VPWR sky130_fd_sc_hd__fill_1
XFILLER_101_597 VGND VGND VPWR VPWR sky130_fd_sc_hd__decap_3
XFILLER_27_320 VGND VGND VPWR VPWR sky130_fd_sc_hd__decap_3
XFILLER_39_191 VGND VGND VPWR VPWR sky130_fd_sc_hd__decap_3
XFILLER_55_662 VGND VGND VPWR VPWR sky130_fd_sc_hd__decap_3
XFILLER_55_673 VGND VGND VPWR VPWR sky130_fd_sc_hd__decap_3
XFILLER_70_610 VGND VGND VPWR VPWR sky130_fd_sc_hd__decap_3
XFILLER_42_301 VGND VGND VPWR VPWR sky130_fd_sc_hd__decap_3
XFILLER_91_14 VGND VGND VPWR VPWR sky130_fd_sc_hd__fill_2
XFILLER_54_172 VGND VGND VPWR VPWR sky130_fd_sc_hd__fill_2
XFILLER_82_492 VGND VGND VPWR VPWR sky130_fd_sc_hd__decap_3
XFILLER_42_323 VGND VGND VPWR VPWR sky130_fd_sc_hd__decap_3
XFILLER_70_643 VGND VGND VPWR VPWR sky130_fd_sc_hd__fill_1
XFILLER_15_559 VGND VGND VPWR VPWR sky130_fd_sc_hd__fill_1
XFILLER_70_654 VGND VGND VPWR VPWR sky130_fd_sc_hd__decap_3
XFILLER_70_687 VGND VGND VPWR VPWR sky130_fd_sc_hd__decap_3
XTAP_TAPCELL_ROW_25_587 VGND VPWR sky130_fd_sc_hd__tapvpwrvgnd_1
XFILLER_11_721 VGND VGND VPWR VPWR sky130_fd_sc_hd__decap_3
XTAP_TAPCELL_ROW_25_598 VGND VPWR sky130_fd_sc_hd__tapvpwrvgnd_1
XFILLER_23_592 VGND VGND VPWR VPWR sky130_fd_sc_hd__decap_3
XFILLER_11_732 VGND VGND VPWR VPWR sky130_fd_sc_hd__decap_3
XFILLER_24_85 VGND VGND VPWR VPWR sky130_fd_sc_hd__decap_3
XFILLER_7_703 VGND VGND VPWR VPWR sky130_fd_sc_hd__decap_3
XFILLER_10_231 VGND VGND VPWR VPWR sky130_fd_sc_hd__fill_1
XFILLER_10_253 VGND VGND VPWR VPWR sky130_fd_sc_hd__decap_3
XFILLER_109_620 VGND VGND VPWR VPWR sky130_fd_sc_hd__decap_3
XFILLER_109_653 VGND VGND VPWR VPWR sky130_fd_sc_hd__decap_3
XFILLER_108_141 VGND VGND VPWR VPWR sky130_fd_sc_hd__decap_3
XFILLER_109_697 VGND VGND VPWR VPWR sky130_fd_sc_hd__decap_3
XFILLER_2_430 VGND VGND VPWR VPWR sky130_fd_sc_hd__fill_2
XFILLER_2_441 VGND VGND VPWR VPWR sky130_fd_sc_hd__decap_3
XFILLER_78_710 VGND VGND VPWR VPWR sky130_fd_sc_hd__decap_3
XFILLER_111_317 VGND VGND VPWR VPWR sky130_fd_sc_hd__decap_3
XFILLER_104_380 VGND VGND VPWR VPWR sky130_fd_sc_hd__decap_3
XFILLER_77_220 VGND VGND VPWR VPWR sky130_fd_sc_hd__decap_3
XFILLER_77_242 VGND VGND VPWR VPWR sky130_fd_sc_hd__decap_3
XFILLER_38_607 VGND VGND VPWR VPWR sky130_fd_sc_hd__decap_3
XFILLER_65_404 VGND VGND VPWR VPWR sky130_fd_sc_hd__decap_3
XFILLER_1_12 VGND VGND VPWR VPWR sky130_fd_sc_hd__decap_3
XFILLER_93_724 VGND VGND VPWR VPWR sky130_fd_sc_hd__decap_3
XFILLER_65_437 VGND VGND VPWR VPWR sky130_fd_sc_hd__decap_3
XFILLER_92_256 VGND VGND VPWR VPWR sky130_fd_sc_hd__decap_3
XFILLER_46_651 VGND VGND VPWR VPWR sky130_fd_sc_hd__decap_3
XFILLER_80_429 VGND VGND VPWR VPWR sky130_fd_sc_hd__decap_3
XFILLER_45_150 VGND VGND VPWR VPWR sky130_fd_sc_hd__decap_3
XFILLER_92_289 VGND VGND VPWR VPWR sky130_fd_sc_hd__decap_3
XFILLER_46_684 VGND VGND VPWR VPWR sky130_fd_sc_hd__decap_3
XFILLER_45_172 VGND VGND VPWR VPWR sky130_fd_sc_hd__decap_3
XFILLER_61_632 VGND VGND VPWR VPWR sky130_fd_sc_hd__decap_3
XFILLER_18_397 VGND VGND VPWR VPWR sky130_fd_sc_hd__decap_3
XFILLER_33_334 VGND VGND VPWR VPWR sky130_fd_sc_hd__fill_2
XTAP_TAPCELL_ROW_44_841 VGND VPWR sky130_fd_sc_hd__tapvpwrvgnd_1
XFILLER_61_665 VGND VGND VPWR VPWR sky130_fd_sc_hd__decap_3
XFILLER_61_676 VGND VGND VPWR VPWR sky130_fd_sc_hd__decap_3
X_4760_ _5015_/A _4760_/B VGND VGND VPWR VPWR _4760_/Y sky130_fd_sc_hd__nand2_2
XFILLER_14_570 VGND VGND VPWR VPWR sky130_fd_sc_hd__decap_3
XFILLER_60_186 VGND VGND VPWR VPWR sky130_fd_sc_hd__decap_3
XFILLER_14_592 VGND VGND VPWR VPWR sky130_fd_sc_hd__decap_3
X_3711_ _3746_/A VGND VGND VPWR VPWR _3735_/A sky130_fd_sc_hd__inv_2
XPHY_EDGE_ROW_112_Right_112 VGND VGND VPWR VPWR sky130_fd_sc_hd__decap_3
X_4691_ _7004_/Q _4665_/X _4804_/A _4757_/A VGND VGND VPWR VPWR _4749_/B sky130_fd_sc_hd__a31o_2
X_6430_ _6619_/A VGND VGND VPWR VPWR _6430_/Y sky130_fd_sc_hd__inv_2
X_3642_ _6718_/Q _6808_/Q _6896_/Q _6944_/Q _3991_/B _3665_/B VGND VGND VPWR VPWR
+ _3642_/X sky130_fd_sc_hd__mux4_2
X_6361_ _6363_/A VGND VGND VPWR VPWR _6361_/Y sky130_fd_sc_hd__inv_2
XPHY_EDGE_ROW_49_Right_49 VGND VGND VPWR VPWR sky130_fd_sc_hd__decap_3
X_3573_ _7316_/Q _3987_/S _4528_/B _7284_/Q VGND VGND VPWR VPWR _3573_/X sky130_fd_sc_hd__a22o_2
XFILLER_115_612 VGND VGND VPWR VPWR sky130_fd_sc_hd__decap_3
XFILLER_115_623 VGND VGND VPWR VPWR sky130_fd_sc_hd__decap_3
X_5312_ _7174_/Q _4864_/X _5315_/S VGND VGND VPWR VPWR _7174_/D sky130_fd_sc_hd__mux2_2
XFILLER_114_111 VGND VGND VPWR VPWR sky130_fd_sc_hd__decap_3
X_6292_ _6608_/A VGND VGND VPWR VPWR _6292_/Y sky130_fd_sc_hd__inv_2
XFILLER_115_656 VGND VGND VPWR VPWR sky130_fd_sc_hd__decap_3
XFILLER_5_290 VGND VGND VPWR VPWR sky130_fd_sc_hd__decap_3
X_5243_ _5243_/A0 _4822_/X _5258_/S VGND VGND VPWR VPWR _7208_/D sky130_fd_sc_hd__mux2_2
XFILLER_69_721 VGND VGND VPWR VPWR sky130_fd_sc_hd__decap_3
XFILLER_69_732 VGND VGND VPWR VPWR sky130_fd_sc_hd__decap_3
XFILLER_114_188 VGND VGND VPWR VPWR sky130_fd_sc_hd__fill_1
XFILLER_96_551 VGND VGND VPWR VPWR sky130_fd_sc_hd__decap_3
XFILLER_29_607 VGND VGND VPWR VPWR sky130_fd_sc_hd__decap_3
XFILLER_68_253 VGND VGND VPWR VPWR sky130_fd_sc_hd__fill_1
X_4125_ _4205_/A _4117_/B _4117_/C _4124_/B VGND VGND VPWR VPWR _4125_/X sky130_fd_sc_hd__a31o_2
XFILLER_84_713 VGND VGND VPWR VPWR sky130_fd_sc_hd__decap_3
XFILLER_29_629 VGND VGND VPWR VPWR sky130_fd_sc_hd__decap_3
XFILLER_110_350 VGND VGND VPWR VPWR sky130_fd_sc_hd__decap_3
XFILLER_96_584 VGND VGND VPWR VPWR sky130_fd_sc_hd__decap_3
XFILLER_96_595 VGND VGND VPWR VPWR sky130_fd_sc_hd__decap_3
XFILLER_68_286 VGND VGND VPWR VPWR sky130_fd_sc_hd__decap_3
XFILLER_83_234 VGND VGND VPWR VPWR sky130_fd_sc_hd__decap_3
X_4056_ _7340_/Q _3935_/S _4428_/B1 _7148_/Q VGND VGND VPWR VPWR _4056_/X sky130_fd_sc_hd__a22o_2
XPHY_EDGE_ROW_58_Right_58 VGND VGND VPWR VPWR sky130_fd_sc_hd__decap_3
XFILLER_83_267 VGND VGND VPWR VPWR sky130_fd_sc_hd__decap_3
XFILLER_37_662 VGND VGND VPWR VPWR sky130_fd_sc_hd__decap_3
XFILLER_37_673 VGND VGND VPWR VPWR sky130_fd_sc_hd__decap_3
XFILLER_71_429 VGND VGND VPWR VPWR sky130_fd_sc_hd__fill_1
XFILLER_52_610 VGND VGND VPWR VPWR sky130_fd_sc_hd__decap_3
XFILLER_24_301 VGND VGND VPWR VPWR sky130_fd_sc_hd__decap_3
XTAP_TAPCELL_ROW_65_1113 VGND VPWR sky130_fd_sc_hd__tapvpwrvgnd_1
XFILLER_24_312 VGND VGND VPWR VPWR sky130_fd_sc_hd__decap_3
XFILLER_64_492 VGND VGND VPWR VPWR sky130_fd_sc_hd__decap_3
XFILLER_52_643 VGND VGND VPWR VPWR sky130_fd_sc_hd__fill_1
XFILLER_24_334 VGND VGND VPWR VPWR sky130_fd_sc_hd__decap_3
XFILLER_52_654 VGND VGND VPWR VPWR sky130_fd_sc_hd__decap_3
XFILLER_24_345 VGND VGND VPWR VPWR sky130_fd_sc_hd__decap_3
XFILLER_101_35 VGND VGND VPWR VPWR sky130_fd_sc_hd__fill_2
XFILLER_52_687 VGND VGND VPWR VPWR sky130_fd_sc_hd__decap_3
XFILLER_12_518 VGND VGND VPWR VPWR sky130_fd_sc_hd__decap_3
XFILLER_101_57 VGND VGND VPWR VPWR sky130_fd_sc_hd__fill_2
XFILLER_51_175 VGND VGND VPWR VPWR sky130_fd_sc_hd__fill_1
X_4958_ _4983_/B VGND VGND VPWR VPWR _4958_/Y sky130_fd_sc_hd__inv_2
XFILLER_101_79 VGND VGND VPWR VPWR sky130_fd_sc_hd__decap_3
X_3909_ hold976/X _5104_/A _3908_/X VGND VGND VPWR VPWR _7379_/D sky130_fd_sc_hd__a21o_2
XTAP_TAPCELL_ROW_22_557 VGND VPWR sky130_fd_sc_hd__tapvpwrvgnd_1
X_4889_ _4890_/B _4889_/B VGND VGND VPWR VPWR _4889_/Y sky130_fd_sc_hd__xnor2_2
X_6628_ _6630_/A VGND VGND VPWR VPWR _6628_/Y sky130_fd_sc_hd__inv_2
XFILLER_20_584 VGND VGND VPWR VPWR sky130_fd_sc_hd__decap_3
XPHY_EDGE_ROW_67_Right_67 VGND VGND VPWR VPWR sky130_fd_sc_hd__decap_3
XPHY_EDGE_ROW_89_Left_213 VGND VGND VPWR VPWR sky130_fd_sc_hd__decap_3
XFILLER_20_595 VGND VGND VPWR VPWR sky130_fd_sc_hd__decap_3
XFILLER_118_450 VGND VGND VPWR VPWR sky130_fd_sc_hd__decap_3
XFILLER_117_6 VGND VGND VPWR VPWR sky130_fd_sc_hd__decap_3
XFILLER_106_601 VGND VGND VPWR VPWR sky130_fd_sc_hd__decap_3
X_6559_ _6624_/A VGND VGND VPWR VPWR _6559_/Y sky130_fd_sc_hd__inv_2
XFILLER_118_461 VGND VGND VPWR VPWR sky130_fd_sc_hd__decap_3
XFILLER_4_728 VGND VGND VPWR VPWR sky130_fd_sc_hd__decap_3
XFILLER_118_483 VGND VGND VPWR VPWR sky130_fd_sc_hd__decap_3
XFILLER_10_21 VGND VGND VPWR VPWR sky130_fd_sc_hd__decap_3
XFILLER_106_634 VGND VGND VPWR VPWR sky130_fd_sc_hd__decap_3
XTAP_TAPCELL_ROW_76_1253 VGND VPWR sky130_fd_sc_hd__tapvpwrvgnd_1
XFILLER_106_645 VGND VGND VPWR VPWR sky130_fd_sc_hd__decap_3
XFILLER_105_122 VGND VGND VPWR VPWR sky130_fd_sc_hd__fill_1
XFILLER_106_678 VGND VGND VPWR VPWR sky130_fd_sc_hd__decap_3
XFILLER_121_615 VGND VGND VPWR VPWR sky130_fd_sc_hd__fill_1
XFILLER_121_626 VGND VGND VPWR VPWR sky130_fd_sc_hd__decap_3
XFILLER_120_103 VGND VGND VPWR VPWR sky130_fd_sc_hd__decap_3
XFILLER_121_659 VGND VGND VPWR VPWR sky130_fd_sc_hd__decap_3
XFILLER_59_231 VGND VGND VPWR VPWR sky130_fd_sc_hd__decap_3
XFILLER_87_551 VGND VGND VPWR VPWR sky130_fd_sc_hd__decap_3
XFILLER_86_58 VGND VGND VPWR VPWR sky130_fd_sc_hd__decap_3
XFILLER_87_573 VGND VGND VPWR VPWR sky130_fd_sc_hd__decap_3
XFILLER_75_724 VGND VGND VPWR VPWR sky130_fd_sc_hd__decap_3
XFILLER_19_106 VGND VGND VPWR VPWR sky130_fd_sc_hd__decap_3
XPHY_EDGE_ROW_76_Right_76 VGND VGND VPWR VPWR sky130_fd_sc_hd__decap_3
XPHY_EDGE_ROW_98_Left_222 VGND VGND VPWR VPWR sky130_fd_sc_hd__decap_3
XFILLER_28_640 VGND VGND VPWR VPWR sky130_fd_sc_hd__decap_3
XFILLER_19_96 VGND VGND VPWR VPWR sky130_fd_sc_hd__fill_1
XFILLER_74_256 VGND VGND VPWR VPWR sky130_fd_sc_hd__fill_2
XFILLER_28_651 VGND VGND VPWR VPWR sky130_fd_sc_hd__decap_3
XFILLER_90_716 VGND VGND VPWR VPWR sky130_fd_sc_hd__decap_3
XFILLER_74_278 VGND VGND VPWR VPWR sky130_fd_sc_hd__decap_3
XFILLER_62_418 VGND VGND VPWR VPWR sky130_fd_sc_hd__fill_2
XFILLER_28_684 VGND VGND VPWR VPWR sky130_fd_sc_hd__decap_3
XTAP_TAPCELL_ROW_2_293 VGND VPWR sky130_fd_sc_hd__tapvpwrvgnd_1
XTAP_TAPCELL_ROW_87_1393 VGND VPWR sky130_fd_sc_hd__tapvpwrvgnd_1
XFILLER_55_492 VGND VGND VPWR VPWR sky130_fd_sc_hd__decap_3
XFILLER_43_632 VGND VGND VPWR VPWR sky130_fd_sc_hd__decap_3
XFILLER_43_665 VGND VGND VPWR VPWR sky130_fd_sc_hd__decap_3
XFILLER_70_462 VGND VGND VPWR VPWR sky130_fd_sc_hd__fill_1
XFILLER_43_676 VGND VGND VPWR VPWR sky130_fd_sc_hd__decap_3
XTAP_TAPCELL_ROW_41_800 VGND VPWR sky130_fd_sc_hd__tapvpwrvgnd_1
XFILLER_42_197 VGND VGND VPWR VPWR sky130_fd_sc_hd__decap_3
XFILLER_30_337 VGND VGND VPWR VPWR sky130_fd_sc_hd__decap_3
XPHY_EDGE_ROW_85_Right_85 VGND VGND VPWR VPWR sky130_fd_sc_hd__decap_3
XFILLER_11_573 VGND VGND VPWR VPWR sky130_fd_sc_hd__decap_3
XFILLER_7_588 VGND VGND VPWR VPWR sky130_fd_sc_hd__decap_3
XFILLER_109_472 VGND VGND VPWR VPWR sky130_fd_sc_hd__fill_2
XFILLER_109_494 VGND VGND VPWR VPWR sky130_fd_sc_hd__decap_3
XFILLER_112_604 VGND VGND VPWR VPWR sky130_fd_sc_hd__decap_3
XFILLER_112_637 VGND VGND VPWR VPWR sky130_fd_sc_hd__decap_3
XFILLER_112_648 VGND VGND VPWR VPWR sky130_fd_sc_hd__decap_3
XPHY_EDGE_ROW_94_Right_94 VGND VGND VPWR VPWR sky130_fd_sc_hd__decap_3
XFILLER_111_158 VGND VGND VPWR VPWR sky130_fd_sc_hd__decap_3
XTAP_TAPCELL_ROW_49_900 VGND VPWR sky130_fd_sc_hd__tapvpwrvgnd_1
XFILLER_66_713 VGND VGND VPWR VPWR sky130_fd_sc_hd__decap_3
XFILLER_111_169 VGND VGND VPWR VPWR sky130_fd_sc_hd__decap_3
XFILLER_38_415 VGND VGND VPWR VPWR sky130_fd_sc_hd__decap_3
XFILLER_78_595 VGND VGND VPWR VPWR sky130_fd_sc_hd__decap_3
XFILLER_120_681 VGND VGND VPWR VPWR sky130_fd_sc_hd__decap_3
XFILLER_76_91 VGND VGND VPWR VPWR sky130_fd_sc_hd__decap_3
XFILLER_93_576 VGND VGND VPWR VPWR sky130_fd_sc_hd__decap_3
XFILLER_65_267 VGND VGND VPWR VPWR sky130_fd_sc_hd__fill_2
XFILLER_19_662 VGND VGND VPWR VPWR sky130_fd_sc_hd__decap_3
XFILLER_81_727 VGND VGND VPWR VPWR sky130_fd_sc_hd__fill_1
XFILLER_19_673 VGND VGND VPWR VPWR sky130_fd_sc_hd__decap_3
XFILLER_80_215 VGND VGND VPWR VPWR sky130_fd_sc_hd__fill_2
XFILLER_46_470 VGND VGND VPWR VPWR sky130_fd_sc_hd__decap_3
XFILLER_34_610 VGND VGND VPWR VPWR sky130_fd_sc_hd__decap_3
XFILLER_80_237 VGND VGND VPWR VPWR sky130_fd_sc_hd__decap_3
XFILLER_34_643 VGND VGND VPWR VPWR sky130_fd_sc_hd__fill_1
XFILLER_80_259 VGND VGND VPWR VPWR sky130_fd_sc_hd__decap_3
XFILLER_34_654 VGND VGND VPWR VPWR sky130_fd_sc_hd__decap_3
XFILLER_34_687 VGND VGND VPWR VPWR sky130_fd_sc_hd__decap_3
X_4812_ _4827_/A _4827_/B VGND VGND VPWR VPWR _4812_/Y sky130_fd_sc_hd__nor2_2
XFILLER_61_473 VGND VGND VPWR VPWR sky130_fd_sc_hd__decap_3
XFILLER_33_175 VGND VGND VPWR VPWR sky130_fd_sc_hd__decap_3
XFILLER_33_197 VGND VGND VPWR VPWR sky130_fd_sc_hd__decap_3
XFILLER_21_337 VGND VGND VPWR VPWR sky130_fd_sc_hd__decap_3
X_4743_ _4069_/Y _4081_/X _4741_/X _4742_/Y VGND VGND VPWR VPWR _4743_/X sky130_fd_sc_hd__a31o_2
XFILLER_21_359 VGND VGND VPWR VPWR sky130_fd_sc_hd__decap_3
XTAP_TAPCELL_ROW_60_1043 VGND VPWR sky130_fd_sc_hd__tapvpwrvgnd_1
XFILLER_119_203 VGND VGND VPWR VPWR sky130_fd_sc_hd__decap_3
XFILLER_119_236 VGND VGND VPWR VPWR sky130_fd_sc_hd__decap_3
X_4674_ _6989_/Q _4677_/B VGND VGND VPWR VPWR _4674_/X sky130_fd_sc_hd__or2_2
X_6413_ _6638_/A VGND VGND VPWR VPWR _6413_/Y sky130_fd_sc_hd__inv_2
X_3625_ _3618_/X _3619_/Y _3620_/X _3624_/X VGND VGND VPWR VPWR _3625_/X sky130_fd_sc_hd__a31o_2
X_7393_ _7398_/CLK _7393_/D _6673_/Y VGND VGND VPWR VPWR _7393_/Q sky130_fd_sc_hd__dfrtp_2
X_6344_ _6660_/A VGND VGND VPWR VPWR _6344_/Y sky130_fd_sc_hd__inv_2
X_3556_ _3556_/A _3556_/B _3556_/C VGND VGND VPWR VPWR _3556_/X sky130_fd_sc_hd__or3_2
XFILLER_115_442 VGND VGND VPWR VPWR sky130_fd_sc_hd__decap_3
XTAP_TAPCELL_ROW_112_1718 VGND VPWR sky130_fd_sc_hd__tapvpwrvgnd_1
XTAP_TAPCELL_ROW_112_1729 VGND VPWR sky130_fd_sc_hd__tapvpwrvgnd_1
XFILLER_115_464 VGND VGND VPWR VPWR sky130_fd_sc_hd__decap_3
XFILLER_103_615 VGND VGND VPWR VPWR sky130_fd_sc_hd__fill_1
X_6275_ _6275_/A VGND VGND VPWR VPWR _6275_/Y sky130_fd_sc_hd__inv_2
XFILLER_88_315 VGND VGND VPWR VPWR sky130_fd_sc_hd__decap_3
XFILLER_103_626 VGND VGND VPWR VPWR sky130_fd_sc_hd__decap_3
X_3487_ _3469_/A _3469_/B _3449_/A _7247_/Q _6980_/Q VGND VGND VPWR VPWR _3487_/X
+ sky130_fd_sc_hd__o2111a_2
XFILLER_88_359 VGND VGND VPWR VPWR sky130_fd_sc_hd__decap_3
XFILLER_103_659 VGND VGND VPWR VPWR sky130_fd_sc_hd__decap_3
XFILLER_102_169 VGND VGND VPWR VPWR sky130_fd_sc_hd__decap_3
XTAP_TAPCELL_ROW_71_1194 VGND VPWR sky130_fd_sc_hd__tapvpwrvgnd_1
X_5157_ _5157_/A0 _5156_/X _5157_/S VGND VGND VPWR VPWR _7248_/D sky130_fd_sc_hd__mux2_2
XFILLER_57_724 VGND VGND VPWR VPWR sky130_fd_sc_hd__decap_3
XFILLER_56_212 VGND VGND VPWR VPWR sky130_fd_sc_hd__decap_3
XFILLER_29_426 VGND VGND VPWR VPWR sky130_fd_sc_hd__decap_3
X_4108_ _4394_/A _4108_/B _4107_/X VGND VGND VPWR VPWR _4142_/C sky130_fd_sc_hd__or3b_2
X_5088_ _5086_/A _4365_/X _5086_/X _5087_/Y _5020_/A VGND VGND VPWR VPWR _5088_/X
+ sky130_fd_sc_hd__a2111o_2
XFILLER_56_256 VGND VGND VPWR VPWR sky130_fd_sc_hd__decap_3
XFILLER_72_716 VGND VGND VPWR VPWR sky130_fd_sc_hd__decap_3
XFILLER_44_418 VGND VGND VPWR VPWR sky130_fd_sc_hd__fill_2
XTAP_TAPCELL_ROW_27_616 VGND VPWR sky130_fd_sc_hd__tapvpwrvgnd_1
XFILLER_84_587 VGND VGND VPWR VPWR sky130_fd_sc_hd__fill_1
XFILLER_71_204 VGND VGND VPWR VPWR sky130_fd_sc_hd__decap_3
XFILLER_112_23 VGND VGND VPWR VPWR sky130_fd_sc_hd__decap_3
X_4039_ _4039_/A _4458_/A VGND VGND VPWR VPWR _4040_/B sky130_fd_sc_hd__and2_2
XFILLER_84_598 VGND VGND VPWR VPWR sky130_fd_sc_hd__decap_3
XFILLER_56_289 VGND VGND VPWR VPWR sky130_fd_sc_hd__decap_3
XFILLER_25_632 VGND VGND VPWR VPWR sky130_fd_sc_hd__decap_3
XFILLER_112_56 VGND VGND VPWR VPWR sky130_fd_sc_hd__decap_3
XFILLER_71_259 VGND VGND VPWR VPWR sky130_fd_sc_hd__decap_3
XFILLER_52_440 VGND VGND VPWR VPWR sky130_fd_sc_hd__decap_3
XFILLER_25_665 VGND VGND VPWR VPWR sky130_fd_sc_hd__decap_3
XTAP_TAPCELL_ROW_123_1869 VGND VPWR sky130_fd_sc_hd__tapvpwrvgnd_1
XFILLER_25_676 VGND VGND VPWR VPWR sky130_fd_sc_hd__decap_3
XFILLER_24_153 VGND VGND VPWR VPWR sky130_fd_sc_hd__decap_3
XFILLER_52_473 VGND VGND VPWR VPWR sky130_fd_sc_hd__decap_3
XFILLER_40_613 VGND VGND VPWR VPWR sky130_fd_sc_hd__decap_3
XFILLER_12_304 VGND VGND VPWR VPWR sky130_fd_sc_hd__decap_3
XFILLER_12_315 VGND VGND VPWR VPWR sky130_fd_sc_hd__fill_1
XFILLER_24_186 VGND VGND VPWR VPWR sky130_fd_sc_hd__decap_3
XFILLER_24_197 VGND VGND VPWR VPWR sky130_fd_sc_hd__decap_3
XFILLER_40_657 VGND VGND VPWR VPWR sky130_fd_sc_hd__decap_3
XFILLER_115_3 VGND VGND VPWR VPWR sky130_fd_sc_hd__decap_3
XFILLER_4_525 VGND VGND VPWR VPWR sky130_fd_sc_hd__decap_3
XFILLER_4_536 VGND VGND VPWR VPWR sky130_fd_sc_hd__decap_3
XFILLER_4_569 VGND VGND VPWR VPWR sky130_fd_sc_hd__decap_3
XFILLER_79_315 VGND VGND VPWR VPWR sky130_fd_sc_hd__decap_3
XFILLER_97_57 VGND VGND VPWR VPWR sky130_fd_sc_hd__fill_2
XFILLER_106_486 VGND VGND VPWR VPWR sky130_fd_sc_hd__fill_2
XFILLER_79_337 VGND VGND VPWR VPWR sky130_fd_sc_hd__decap_3
XFILLER_97_79 VGND VGND VPWR VPWR sky130_fd_sc_hd__decap_3
XTAP_TAPCELL_ROW_7_352 VGND VPWR sky130_fd_sc_hd__tapvpwrvgnd_1
XFILLER_121_445 VGND VGND VPWR VPWR sky130_fd_sc_hd__decap_3
XTAP_TAPCELL_ROW_7_363 VGND VPWR sky130_fd_sc_hd__tapvpwrvgnd_1
XFILLER_121_467 VGND VGND VPWR VPWR sky130_fd_sc_hd__decap_3
XFILLER_48_713 VGND VGND VPWR VPWR sky130_fd_sc_hd__decap_3
XFILLER_102_681 VGND VGND VPWR VPWR sky130_fd_sc_hd__decap_3
XTAP_TAPCELL_ROW_89_1422 VGND VPWR sky130_fd_sc_hd__tapvpwrvgnd_1
XFILLER_101_180 VGND VGND VPWR VPWR sky130_fd_sc_hd__decap_3
XFILLER_75_554 VGND VGND VPWR VPWR sky130_fd_sc_hd__decap_3
XFILLER_47_256 VGND VGND VPWR VPWR sky130_fd_sc_hd__decap_3
XFILLER_63_727 VGND VGND VPWR VPWR sky130_fd_sc_hd__fill_1
XFILLER_35_429 VGND VGND VPWR VPWR sky130_fd_sc_hd__decap_3
XFILLER_16_610 VGND VGND VPWR VPWR sky130_fd_sc_hd__decap_3
XFILLER_62_226 VGND VGND VPWR VPWR sky130_fd_sc_hd__decap_3
XFILLER_46_83 VGND VGND VPWR VPWR sky130_fd_sc_hd__fill_1
XFILLER_28_492 VGND VGND VPWR VPWR sky130_fd_sc_hd__decap_3
XFILLER_90_557 VGND VGND VPWR VPWR sky130_fd_sc_hd__decap_3
XFILLER_16_643 VGND VGND VPWR VPWR sky130_fd_sc_hd__fill_1
XFILLER_62_259 VGND VGND VPWR VPWR sky130_fd_sc_hd__decap_3
XFILLER_16_654 VGND VGND VPWR VPWR sky130_fd_sc_hd__decap_3
XFILLER_15_120 VGND VGND VPWR VPWR sky130_fd_sc_hd__decap_3
XFILLER_16_687 VGND VGND VPWR VPWR sky130_fd_sc_hd__decap_3
XFILLER_15_175 VGND VGND VPWR VPWR sky130_fd_sc_hd__decap_3
XFILLER_70_281 VGND VGND VPWR VPWR sky130_fd_sc_hd__decap_3
XFILLER_43_495 VGND VGND VPWR VPWR sky130_fd_sc_hd__decap_3
XFILLER_31_635 VGND VGND VPWR VPWR sky130_fd_sc_hd__decap_3
XFILLER_30_112 VGND VGND VPWR VPWR sky130_fd_sc_hd__fill_2
XFILLER_31_668 VGND VGND VPWR VPWR sky130_fd_sc_hd__decap_3
XFILLER_31_679 VGND VGND VPWR VPWR sky130_fd_sc_hd__decap_3
XFILLER_7_11 VGND VGND VPWR VPWR sky130_fd_sc_hd__decap_3
XFILLER_30_178 VGND VGND VPWR VPWR sky130_fd_sc_hd__decap_3
XFILLER_117_718 VGND VGND VPWR VPWR sky130_fd_sc_hd__decap_3
XFILLER_117_729 VGND VGND VPWR VPWR sky130_fd_sc_hd__decap_3
XFILLER_7_385 VGND VGND VPWR VPWR sky130_fd_sc_hd__decap_3
XFILLER_116_239 VGND VGND VPWR VPWR sky130_fd_sc_hd__decap_3
X_3410_ _7219_/Q _4307_/A2 _4528_/B _7032_/Q VGND VGND VPWR VPWR _3410_/X sky130_fd_sc_hd__a22o_2
XFILLER_7_396 VGND VGND VPWR VPWR sky130_fd_sc_hd__decap_3
X_4390_ _7241_/Q _4433_/B _3945_/S _7209_/Q VGND VGND VPWR VPWR _4390_/X sky130_fd_sc_hd__a22o_2
XFILLER_98_613 VGND VGND VPWR VPWR sky130_fd_sc_hd__decap_3
X_3341_ _3341_/A VGND VGND VPWR VPWR _5666_/A sky130_fd_sc_hd__inv_2
XFILLER_98_657 VGND VGND VPWR VPWR sky130_fd_sc_hd__decap_3
XFILLER_3_591 VGND VGND VPWR VPWR sky130_fd_sc_hd__decap_3
XFILLER_30_3 VGND VGND VPWR VPWR sky130_fd_sc_hd__fill_2
XFILLER_112_445 VGND VGND VPWR VPWR sky130_fd_sc_hd__decap_3
XFILLER_100_607 VGND VGND VPWR VPWR sky130_fd_sc_hd__decap_3
X_5011_ _5040_/S _6991_/D _5010_/X VGND VGND VPWR VPWR _5011_/X sky130_fd_sc_hd__o21a_2
Xhold1008 _7265_/Q VGND VGND VPWR VPWR _4946_/A0 sky130_fd_sc_hd__dlygate4sd3_1
XFILLER_85_329 VGND VGND VPWR VPWR sky130_fd_sc_hd__decap_3
XFILLER_39_724 VGND VGND VPWR VPWR sky130_fd_sc_hd__decap_3
XFILLER_112_489 VGND VGND VPWR VPWR sky130_fd_sc_hd__decap_3
Xhold1019 _7203_/Q VGND VGND VPWR VPWR _5253_/A0 sky130_fd_sc_hd__dlygate4sd3_1
XFILLER_38_212 VGND VGND VPWR VPWR sky130_fd_sc_hd__decap_3
XFILLER_38_256 VGND VGND VPWR VPWR sky130_fd_sc_hd__decap_3
XFILLER_54_716 VGND VGND VPWR VPWR sky130_fd_sc_hd__decap_3
XFILLER_38_289 VGND VGND VPWR VPWR sky130_fd_sc_hd__decap_3
X_6962_ clkload8/A _6962_/D VGND VGND VPWR VPWR _6962_/Q sky130_fd_sc_hd__dfxtp_2
XTAP_TAPCELL_ROW_109_1680 VGND VPWR sky130_fd_sc_hd__tapvpwrvgnd_1
XFILLER_53_237 VGND VGND VPWR VPWR sky130_fd_sc_hd__decap_3
XFILLER_53_259 VGND VGND VPWR VPWR sky130_fd_sc_hd__decap_3
X_6893_ _7403_/CLK _6893_/D VGND VGND VPWR VPWR _6893_/Q sky130_fd_sc_hd__dfxtp_2
XFILLER_81_579 VGND VGND VPWR VPWR sky130_fd_sc_hd__decap_3
XFILLER_34_451 VGND VGND VPWR VPWR sky130_fd_sc_hd__decap_3
XTAP_TAPCELL_ROW_52_939 VGND VPWR sky130_fd_sc_hd__tapvpwrvgnd_1
XFILLER_22_613 VGND VGND VPWR VPWR sky130_fd_sc_hd__decap_3
XFILLER_61_281 VGND VGND VPWR VPWR sky130_fd_sc_hd__decap_3
XFILLER_22_657 VGND VGND VPWR VPWR sky130_fd_sc_hd__decap_3
XFILLER_21_156 VGND VGND VPWR VPWR sky130_fd_sc_hd__fill_1
XFILLER_21_178 VGND VGND VPWR VPWR sky130_fd_sc_hd__decap_3
XTAP_TAPCELL_ROW_32_685 VGND VPWR sky130_fd_sc_hd__tapvpwrvgnd_1
X_4726_ _4832_/A _5655_/A _3670_/X _4467_/B VGND VGND VPWR VPWR _4726_/X sky130_fd_sc_hd__o211a_2
XFILLER_30_690 VGND VGND VPWR VPWR sky130_fd_sc_hd__decap_3
XFILLER_108_707 VGND VGND VPWR VPWR sky130_fd_sc_hd__decap_3
X_4657_ _4720_/A _4655_/X _4829_/A VGND VGND VPWR VPWR _4658_/B sky130_fd_sc_hd__a21oi_2
XFILLER_107_217 VGND VGND VPWR VPWR sky130_fd_sc_hd__fill_1
Xhold820 _6940_/Q VGND VGND VPWR VPWR _6940_/D sky130_fd_sc_hd__dlygate4sd3_1
X_7376_ _7386_/CLK _7376_/D _6656_/Y VGND VGND VPWR VPWR _7376_/Q sky130_fd_sc_hd__dfrtp_2
Xhold831 _6761_/Q VGND VGND VPWR VPWR _6761_/D sky130_fd_sc_hd__dlygate4sd3_1
Xhold842 _7087_/Q VGND VGND VPWR VPWR _7087_/D sky130_fd_sc_hd__dlygate4sd3_1
XTAP_TAPCELL_ROW_73_1212 VGND VPWR sky130_fd_sc_hd__tapvpwrvgnd_1
Xmax_cap561 _3535_/B VGND VGND VPWR VPWR _5071_/A sky130_fd_sc_hd__clkbuf_2
Xhold853 _7111_/Q VGND VGND VPWR VPWR _7111_/D sky130_fd_sc_hd__dlygate4sd3_1
X_6327_ _6680_/A VGND VGND VPWR VPWR _6327_/Y sky130_fd_sc_hd__inv_2
Xhold864 _7105_/Q VGND VGND VPWR VPWR _7105_/D sky130_fd_sc_hd__dlygate4sd3_1
XFILLER_1_517 VGND VGND VPWR VPWR sky130_fd_sc_hd__decap_3
X_3539_ _3544_/A _3544_/B VGND VGND VPWR VPWR _3547_/A sky130_fd_sc_hd__nand2_2
Xhold875 _7077_/Q VGND VGND VPWR VPWR _7077_/D sky130_fd_sc_hd__dlygate4sd3_1
XFILLER_107_34 VGND VGND VPWR VPWR sky130_fd_sc_hd__decap_3
XFILLER_89_635 VGND VGND VPWR VPWR sky130_fd_sc_hd__decap_3
XFILLER_88_112 VGND VGND VPWR VPWR sky130_fd_sc_hd__decap_3
Xhold886 _7060_/Q VGND VGND VPWR VPWR _7060_/D sky130_fd_sc_hd__dlygate4sd3_1
Xhold897 _7088_/Q VGND VGND VPWR VPWR _7088_/D sky130_fd_sc_hd__dlygate4sd3_1
XFILLER_89_668 VGND VGND VPWR VPWR sky130_fd_sc_hd__decap_3
XFILLER_67_27 VGND VGND VPWR VPWR sky130_fd_sc_hd__decap_3
XFILLER_89_679 VGND VGND VPWR VPWR sky130_fd_sc_hd__decap_3
XFILLER_88_156 VGND VGND VPWR VPWR sky130_fd_sc_hd__decap_3
XFILLER_76_307 VGND VGND VPWR VPWR sky130_fd_sc_hd__fill_1
XFILLER_103_478 VGND VGND VPWR VPWR sky130_fd_sc_hd__decap_3
X_5209_ _5209_/A _5225_/B VGND VGND VPWR VPWR _7224_/D sky130_fd_sc_hd__and2_2
XFILLER_76_329 VGND VGND VPWR VPWR sky130_fd_sc_hd__decap_3
XTAP_TAPCELL_ROW_4_322 VGND VPWR sky130_fd_sc_hd__tapvpwrvgnd_1
XFILLER_29_201 VGND VGND VPWR VPWR sky130_fd_sc_hd__fill_1
XFILLER_29_223 VGND VGND VPWR VPWR sky130_fd_sc_hd__fill_1
XFILLER_123_11 VGND VGND VPWR VPWR sky130_fd_sc_hd__decap_3
XFILLER_29_256 VGND VGND VPWR VPWR sky130_fd_sc_hd__fill_2
XFILLER_45_727 VGND VGND VPWR VPWR sky130_fd_sc_hd__fill_1
XFILLER_123_66 VGND VGND VPWR VPWR sky130_fd_sc_hd__decap_3
XFILLER_123_77 VGND VGND VPWR VPWR sky130_fd_sc_hd__decap_3
XFILLER_72_524 VGND VGND VPWR VPWR sky130_fd_sc_hd__decap_3
XFILLER_123_88 VGND VGND VPWR VPWR sky130_fd_sc_hd__decap_3
XFILLER_83_48 VGND VGND VPWR VPWR sky130_fd_sc_hd__decap_3
XFILLER_44_237 VGND VGND VPWR VPWR sky130_fd_sc_hd__decap_3
XFILLER_60_719 VGND VGND VPWR VPWR sky130_fd_sc_hd__decap_3
XTAP_TAPCELL_ROW_84_1363 VGND VPWR sky130_fd_sc_hd__tapvpwrvgnd_1
XFILLER_16_75 VGND VGND VPWR VPWR sky130_fd_sc_hd__decap_3
XFILLER_25_484 VGND VGND VPWR VPWR sky130_fd_sc_hd__decap_3
XFILLER_13_635 VGND VGND VPWR VPWR sky130_fd_sc_hd__decap_3
XFILLER_40_421 VGND VGND VPWR VPWR sky130_fd_sc_hd__decap_3
XFILLER_52_292 VGND VGND VPWR VPWR sky130_fd_sc_hd__decap_3
XFILLER_9_606 VGND VGND VPWR VPWR sky130_fd_sc_hd__decap_3
XFILLER_9_617 VGND VGND VPWR VPWR sky130_fd_sc_hd__decap_3
XFILLER_13_668 VGND VGND VPWR VPWR sky130_fd_sc_hd__decap_3
XFILLER_13_679 VGND VGND VPWR VPWR sky130_fd_sc_hd__decap_3
XFILLER_40_465 VGND VGND VPWR VPWR sky130_fd_sc_hd__decap_3
XFILLER_12_156 VGND VGND VPWR VPWR sky130_fd_sc_hd__decap_3
XFILLER_40_498 VGND VGND VPWR VPWR sky130_fd_sc_hd__decap_3
XFILLER_12_189 VGND VGND VPWR VPWR sky130_fd_sc_hd__decap_3
XFILLER_32_85 VGND VGND VPWR VPWR sky130_fd_sc_hd__fill_1
XFILLER_4_333 VGND VGND VPWR VPWR sky130_fd_sc_hd__decap_3
XFILLER_113_209 VGND VGND VPWR VPWR sky130_fd_sc_hd__decap_3
XFILLER_79_101 VGND VGND VPWR VPWR sky130_fd_sc_hd__decap_3
XFILLER_122_710 VGND VGND VPWR VPWR sky130_fd_sc_hd__decap_3
XFILLER_106_283 VGND VGND VPWR VPWR sky130_fd_sc_hd__decap_3
XFILLER_79_134 VGND VGND VPWR VPWR sky130_fd_sc_hd__decap_3
XFILLER_121_220 VGND VGND VPWR VPWR sky130_fd_sc_hd__decap_3
XFILLER_67_307 VGND VGND VPWR VPWR sky130_fd_sc_hd__decap_3
XFILLER_79_167 VGND VGND VPWR VPWR sky130_fd_sc_hd__fill_1
XFILLER_0_561 VGND VGND VPWR VPWR sky130_fd_sc_hd__decap_3
XFILLER_95_638 VGND VGND VPWR VPWR sky130_fd_sc_hd__decap_3
XFILLER_94_115 VGND VGND VPWR VPWR sky130_fd_sc_hd__decap_3
XFILLER_48_510 VGND VGND VPWR VPWR sky130_fd_sc_hd__decap_3
XFILLER_121_275 VGND VGND VPWR VPWR sky130_fd_sc_hd__fill_2
XFILLER_88_690 VGND VGND VPWR VPWR sky130_fd_sc_hd__decap_3
XFILLER_57_60 VGND VGND VPWR VPWR sky130_fd_sc_hd__fill_1
XFILLER_36_716 VGND VGND VPWR VPWR sky130_fd_sc_hd__decap_3
XFILLER_48_587 VGND VGND VPWR VPWR sky130_fd_sc_hd__fill_1
XFILLER_35_204 VGND VGND VPWR VPWR sky130_fd_sc_hd__decap_3
XFILLER_35_237 VGND VGND VPWR VPWR sky130_fd_sc_hd__decap_3
XFILLER_63_557 VGND VGND VPWR VPWR sky130_fd_sc_hd__decap_3
XPHY_EDGE_ROW_35_Left_159 VGND VGND VPWR VPWR sky130_fd_sc_hd__decap_3
XFILLER_90_365 VGND VGND VPWR VPWR sky130_fd_sc_hd__decap_3
XFILLER_16_462 VGND VGND VPWR VPWR sky130_fd_sc_hd__decap_3
XFILLER_50_218 VGND VGND VPWR VPWR sky130_fd_sc_hd__fill_1
X_3890_ _6963_/Q _3892_/A2 _3890_/B1 _6945_/Q VGND VGND VPWR VPWR _3890_/X sky130_fd_sc_hd__a22o_2
XFILLER_43_281 VGND VGND VPWR VPWR sky130_fd_sc_hd__decap_3
XFILLER_31_421 VGND VGND VPWR VPWR sky130_fd_sc_hd__decap_3
XFILLER_31_476 VGND VGND VPWR VPWR sky130_fd_sc_hd__decap_3
XFILLER_31_498 VGND VGND VPWR VPWR sky130_fd_sc_hd__decap_3
XFILLER_12_690 VGND VGND VPWR VPWR sky130_fd_sc_hd__decap_3
XFILLER_78_3 VGND VGND VPWR VPWR sky130_fd_sc_hd__decap_3
XFILLER_8_672 VGND VGND VPWR VPWR sky130_fd_sc_hd__decap_3
XFILLER_117_526 VGND VGND VPWR VPWR sky130_fd_sc_hd__decap_3
X_7230_ _7359_/CLK _7230_/D _6510_/Y VGND VGND VPWR VPWR _7230_/Q sky130_fd_sc_hd__dfrtp_2
XFILLER_117_559 VGND VGND VPWR VPWR sky130_fd_sc_hd__fill_1
X_4442_ _4813_/A _4827_/A VGND VGND VPWR VPWR _4779_/A sky130_fd_sc_hd__or2_2
XFILLER_7_193 VGND VGND VPWR VPWR sky130_fd_sc_hd__fill_2
XPHY_EDGE_ROW_44_Left_168 VGND VGND VPWR VPWR sky130_fd_sc_hd__decap_3
X_7161_ _7356_/CLK _7161_/D _6441_/Y VGND VGND VPWR VPWR _7161_/Q sky130_fd_sc_hd__dfrtp_2
X_4373_ _5018_/A _5018_/B VGND VGND VPWR VPWR _4373_/Y sky130_fd_sc_hd__nand2_2
XFILLER_113_721 VGND VGND VPWR VPWR sky130_fd_sc_hd__decap_3
XFILLER_98_421 VGND VGND VPWR VPWR sky130_fd_sc_hd__decap_3
XFILLER_113_732 VGND VGND VPWR VPWR sky130_fd_sc_hd__decap_3
X_3324_ _6981_/Q _4467_/A _4696_/B VGND VGND VPWR VPWR _3324_/X sky130_fd_sc_hd__or3_2
XFILLER_98_454 VGND VGND VPWR VPWR sky130_fd_sc_hd__decap_3
X_7092_ _7318_/CLK _7092_/D _6372_/Y VGND VGND VPWR VPWR _7092_/Q sky130_fd_sc_hd__dfrtp_2
XFILLER_112_242 VGND VGND VPWR VPWR sky130_fd_sc_hd__decap_3
XFILLER_86_616 VGND VGND VPWR VPWR sky130_fd_sc_hd__decap_3
XFILLER_112_253 VGND VGND VPWR VPWR sky130_fd_sc_hd__decap_3
XFILLER_58_318 VGND VGND VPWR VPWR sky130_fd_sc_hd__decap_3
XFILLER_85_137 VGND VGND VPWR VPWR sky130_fd_sc_hd__decap_3
XFILLER_66_340 VGND VGND VPWR VPWR sky130_fd_sc_hd__decap_3
XFILLER_94_660 VGND VGND VPWR VPWR sky130_fd_sc_hd__decap_3
XFILLER_27_727 VGND VGND VPWR VPWR sky130_fd_sc_hd__fill_1
XFILLER_94_693 VGND VGND VPWR VPWR sky130_fd_sc_hd__decap_3
XFILLER_81_310 VGND VGND VPWR VPWR sky130_fd_sc_hd__decap_3
XFILLER_93_181 VGND VGND VPWR VPWR sky130_fd_sc_hd__decap_3
XPHY_EDGE_ROW_53_Left_177 VGND VGND VPWR VPWR sky130_fd_sc_hd__decap_3
XTAP_TAPCELL_ROW_37_744 VGND VPWR sky130_fd_sc_hd__tapvpwrvgnd_1
XFILLER_26_259 VGND VGND VPWR VPWR sky130_fd_sc_hd__fill_2
X_6945_ clkload4/A _6945_/D VGND VGND VPWR VPWR _6945_/Q sky130_fd_sc_hd__dfxtp_2
XFILLER_42_719 VGND VGND VPWR VPWR sky130_fd_sc_hd__decap_3
XTAP_TAPCELL_ROW_120_1828 VGND VPWR sky130_fd_sc_hd__tapvpwrvgnd_1
X_6876_ _6926_/CLK _6876_/D VGND VGND VPWR VPWR _6876_/Q sky130_fd_sc_hd__dfxtp_2
XFILLER_22_421 VGND VGND VPWR VPWR sky130_fd_sc_hd__decap_3
XTAP_TAPCELL_ROW_17_490 VGND VPWR sky130_fd_sc_hd__tapvpwrvgnd_1
XFILLER_10_616 VGND VGND VPWR VPWR sky130_fd_sc_hd__decap_3
XFILLER_108_504 VGND VGND VPWR VPWR sky130_fd_sc_hd__decap_3
X_4709_ _7002_/Q _7003_/Q _4826_/A VGND VGND VPWR VPWR _4801_/A sky130_fd_sc_hd__and3_2
XFILLER_108_526 VGND VGND VPWR VPWR sky130_fd_sc_hd__decap_3
XPHY_EDGE_ROW_62_Left_186 VGND VGND VPWR VPWR sky130_fd_sc_hd__decap_3
XFILLER_108_548 VGND VGND VPWR VPWR sky130_fd_sc_hd__decap_3
XFILLER_118_44 VGND VGND VPWR VPWR sky130_fd_sc_hd__decap_3
XFILLER_78_15 VGND VGND VPWR VPWR sky130_fd_sc_hd__decap_3
XFILLER_118_77 VGND VGND VPWR VPWR sky130_fd_sc_hd__decap_3
XFILLER_104_710 VGND VGND VPWR VPWR sky130_fd_sc_hd__decap_3
Xhold650 _6742_/Q VGND VGND VPWR VPWR _6742_/D sky130_fd_sc_hd__dlygate4sd3_1
X_7359_ _7359_/CLK _7359_/D _6639_/Y VGND VGND VPWR VPWR _7359_/Q sky130_fd_sc_hd__dfrtp_2
XFILLER_118_88 VGND VGND VPWR VPWR sky130_fd_sc_hd__decap_3
Xhold661 _6810_/Q VGND VGND VPWR VPWR _6810_/D sky130_fd_sc_hd__dlygate4sd3_1
XFILLER_1_314 VGND VGND VPWR VPWR sky130_fd_sc_hd__fill_1
XFILLER_116_581 VGND VGND VPWR VPWR sky130_fd_sc_hd__decap_3
Xhold672 _6751_/Q VGND VGND VPWR VPWR _6751_/D sky130_fd_sc_hd__dlygate4sd3_1
XFILLER_116_592 VGND VGND VPWR VPWR sky130_fd_sc_hd__decap_3
Xhold683 _6900_/Q VGND VGND VPWR VPWR _6900_/D sky130_fd_sc_hd__dlygate4sd3_1
Xhold694 _6841_/Q VGND VGND VPWR VPWR _6841_/D sky130_fd_sc_hd__dlygate4sd3_1
XFILLER_89_476 VGND VGND VPWR VPWR sky130_fd_sc_hd__decap_3
XFILLER_103_264 VGND VGND VPWR VPWR sky130_fd_sc_hd__fill_1
XFILLER_77_638 VGND VGND VPWR VPWR sky130_fd_sc_hd__decap_3
XFILLER_103_275 VGND VGND VPWR VPWR sky130_fd_sc_hd__fill_2
XFILLER_57_340 VGND VGND VPWR VPWR sky130_fd_sc_hd__fill_2
XFILLER_92_619 VGND VGND VPWR VPWR sky130_fd_sc_hd__decap_3
XPHY_EDGE_ROW_71_Left_195 VGND VGND VPWR VPWR sky130_fd_sc_hd__decap_3
XFILLER_94_58 VGND VGND VPWR VPWR sky130_fd_sc_hd__decap_3
XFILLER_18_716 VGND VGND VPWR VPWR sky130_fd_sc_hd__decap_3
XFILLER_85_671 VGND VGND VPWR VPWR sky130_fd_sc_hd__fill_1
XFILLER_85_682 VGND VGND VPWR VPWR sky130_fd_sc_hd__decap_3
XFILLER_57_373 VGND VGND VPWR VPWR sky130_fd_sc_hd__fill_2
XFILLER_17_215 VGND VGND VPWR VPWR sky130_fd_sc_hd__decap_3
XFILLER_27_63 VGND VGND VPWR VPWR sky130_fd_sc_hd__decap_3
XFILLER_17_237 VGND VGND VPWR VPWR sky130_fd_sc_hd__decap_3
XFILLER_84_192 VGND VGND VPWR VPWR sky130_fd_sc_hd__decap_3
XFILLER_72_354 VGND VGND VPWR VPWR sky130_fd_sc_hd__fill_2
XFILLER_72_365 VGND VGND VPWR VPWR sky130_fd_sc_hd__decap_3
XFILLER_72_387 VGND VGND VPWR VPWR sky130_fd_sc_hd__decap_3
XFILLER_25_270 VGND VGND VPWR VPWR sky130_fd_sc_hd__decap_3
XFILLER_25_281 VGND VGND VPWR VPWR sky130_fd_sc_hd__decap_3
XFILLER_40_251 VGND VGND VPWR VPWR sky130_fd_sc_hd__fill_1
XFILLER_9_458 VGND VGND VPWR VPWR sky130_fd_sc_hd__decap_3
XTAP_TAPCELL_ROW_97_1532 VGND VPWR sky130_fd_sc_hd__tapvpwrvgnd_1
XFILLER_5_620 VGND VGND VPWR VPWR sky130_fd_sc_hd__decap_3
XFILLER_5_653 VGND VGND VPWR VPWR sky130_fd_sc_hd__decap_3
XFILLER_99_218 VGND VGND VPWR VPWR sky130_fd_sc_hd__decap_3
XFILLER_114_529 VGND VGND VPWR VPWR sky130_fd_sc_hd__decap_3
XFILLER_107_570 VGND VGND VPWR VPWR sky130_fd_sc_hd__decap_3
XFILLER_5_697 VGND VGND VPWR VPWR sky130_fd_sc_hd__decap_3
XFILLER_4_185 VGND VGND VPWR VPWR sky130_fd_sc_hd__decap_3
XFILLER_4_45 VGND VGND VPWR VPWR sky130_fd_sc_hd__fill_1
XFILLER_122_551 VGND VGND VPWR VPWR sky130_fd_sc_hd__decap_3
XFILLER_68_616 VGND VGND VPWR VPWR sky130_fd_sc_hd__decap_3
XFILLER_110_713 VGND VGND VPWR VPWR sky130_fd_sc_hd__decap_3
XFILLER_122_584 VGND VGND VPWR VPWR sky130_fd_sc_hd__decap_3
XFILLER_95_435 VGND VGND VPWR VPWR sky130_fd_sc_hd__decap_3
XFILLER_122_595 VGND VGND VPWR VPWR sky130_fd_sc_hd__decap_3
XFILLER_0_380 VGND VGND VPWR VPWR sky130_fd_sc_hd__fill_1
XFILLER_76_660 VGND VGND VPWR VPWR sky130_fd_sc_hd__decap_3
XFILLER_48_351 VGND VGND VPWR VPWR sky130_fd_sc_hd__decap_3
XFILLER_76_693 VGND VGND VPWR VPWR sky130_fd_sc_hd__decap_3
XFILLER_75_181 VGND VGND VPWR VPWR sky130_fd_sc_hd__fill_1
XFILLER_91_641 VGND VGND VPWR VPWR sky130_fd_sc_hd__decap_3
XFILLER_63_332 VGND VGND VPWR VPWR sky130_fd_sc_hd__decap_3
XFILLER_84_80 VGND VGND VPWR VPWR sky130_fd_sc_hd__decap_3
XFILLER_63_343 VGND VGND VPWR VPWR sky130_fd_sc_hd__decap_3
XFILLER_36_557 VGND VGND VPWR VPWR sky130_fd_sc_hd__fill_2
Xplace310 _5146_/B1 VGND VGND VPWR VPWR _4811_/C sky130_fd_sc_hd__buf_2
Xplace321 _5292_/S VGND VGND VPWR VPWR _5278_/S sky130_fd_sc_hd__buf_2
XFILLER_51_505 VGND VGND VPWR VPWR sky130_fd_sc_hd__fill_2
XFILLER_24_719 VGND VGND VPWR VPWR sky130_fd_sc_hd__decap_3
XTAP_TAPCELL_ROW_106_1650 VGND VPWR sky130_fd_sc_hd__tapvpwrvgnd_1
XTAP_TAPCELL_ROW_34_703 VGND VPWR sky130_fd_sc_hd__tapvpwrvgnd_1
X_4991_ _5004_/A _5004_/B _4988_/A VGND VGND VPWR VPWR _4991_/Y sky130_fd_sc_hd__a21oi_2
Xplace332 _5737_/S VGND VGND VPWR VPWR _5712_/S sky130_fd_sc_hd__buf_2
Xplace343 _5398_/S VGND VGND VPWR VPWR _5427_/S sky130_fd_sc_hd__buf_2
XFILLER_91_685 VGND VGND VPWR VPWR sky130_fd_sc_hd__decap_3
XFILLER_23_207 VGND VGND VPWR VPWR sky130_fd_sc_hd__decap_3
XTAP_TAPCELL_ROW_34_714 VGND VPWR sky130_fd_sc_hd__tapvpwrvgnd_1
Xplace354 _4335_/B1 VGND VGND VPWR VPWR _4351_/A2 sky130_fd_sc_hd__buf_2
XFILLER_51_527 VGND VGND VPWR VPWR sky130_fd_sc_hd__decap_3
XFILLER_23_218 VGND VGND VPWR VPWR sky130_fd_sc_hd__decap_3
X_6730_ _6978_/CLK _6730_/D VGND VGND VPWR VPWR _6730_/Q sky130_fd_sc_hd__dfxtp_2
XFILLER_23_229 VGND VGND VPWR VPWR sky130_fd_sc_hd__decap_3
Xplace365 _3409_/X VGND VGND VPWR VPWR _4352_/B1 sky130_fd_sc_hd__buf_2
Xplace376 _5151_/A VGND VGND VPWR VPWR _3904_/A sky130_fd_sc_hd__buf_2
XFILLER_16_281 VGND VGND VPWR VPWR sky130_fd_sc_hd__decap_3
Xplace387 _5225_/B VGND VGND VPWR VPWR _5223_/B sky130_fd_sc_hd__buf_2
Xplace398 _5294_/Y VGND VGND VPWR VPWR _7412_/A sky130_fd_sc_hd__buf_2
X_6661_ _6664_/A VGND VGND VPWR VPWR _6661_/Y sky130_fd_sc_hd__inv_2
XFILLER_31_240 VGND VGND VPWR VPWR sky130_fd_sc_hd__decap_3
X_3873_ _3733_/X _3870_/X _3872_/X _3923_/A1 VGND VGND VPWR VPWR _3874_/B sky130_fd_sc_hd__a22o_2
XFILLER_31_284 VGND VGND VPWR VPWR sky130_fd_sc_hd__decap_3
X_6592_ _6633_/A VGND VGND VPWR VPWR _6592_/Y sky130_fd_sc_hd__inv_2
XFILLER_8_480 VGND VGND VPWR VPWR sky130_fd_sc_hd__decap_3
XTAP_TAPCELL_ROW_57_1004 VGND VPWR sky130_fd_sc_hd__tapvpwrvgnd_1
X_7213_ _7406_/CLK _7213_/D _6493_/Y VGND VGND VPWR VPWR _7213_/Q sky130_fd_sc_hd__dfrtp_2
X_4425_ _4425_/A _4649_/B _4425_/C VGND VGND VPWR VPWR _4426_/B sky130_fd_sc_hd__and3_2
XTAP_TAPCELL_ROW_117_1790 VGND VPWR sky130_fd_sc_hd__tapvpwrvgnd_1
X_7144_ _7368_/CLK _7144_/D _6424_/Y VGND VGND VPWR VPWR _7144_/Q sky130_fd_sc_hd__dfrtp_2
X_4356_ _7012_/Q _4356_/A2 _4270_/B _7353_/Q _4355_/X VGND VGND VPWR VPWR _4356_/X
+ sky130_fd_sc_hd__a221o_2
XFILLER_113_573 VGND VGND VPWR VPWR sky130_fd_sc_hd__decap_3
XFILLER_59_638 VGND VGND VPWR VPWR sky130_fd_sc_hd__decap_3
XFILLER_101_724 VGND VGND VPWR VPWR sky130_fd_sc_hd__decap_3
X_7075_ _7398_/CLK _7075_/D _6355_/Y VGND VGND VPWR VPWR _7075_/Q sky130_fd_sc_hd__dfrtp_2
XFILLER_98_284 VGND VGND VPWR VPWR sky130_fd_sc_hd__decap_3
XFILLER_100_212 VGND VGND VPWR VPWR sky130_fd_sc_hd__decap_3
X_4287_ _7286_/Q _5157_/S _4352_/B1 _7158_/Q VGND VGND VPWR VPWR _4288_/D sky130_fd_sc_hd__a22o_2
XFILLER_86_457 VGND VGND VPWR VPWR sky130_fd_sc_hd__decap_3
XFILLER_100_245 VGND VGND VPWR VPWR sky130_fd_sc_hd__decap_3
XFILLER_74_619 VGND VGND VPWR VPWR sky130_fd_sc_hd__decap_3
XFILLER_100_256 VGND VGND VPWR VPWR sky130_fd_sc_hd__decap_3
XFILLER_67_671 VGND VGND VPWR VPWR sky130_fd_sc_hd__fill_1
XFILLER_67_682 VGND VGND VPWR VPWR sky130_fd_sc_hd__decap_3
XFILLER_54_321 VGND VGND VPWR VPWR sky130_fd_sc_hd__decap_3
XTAP_TAPCELL_ROW_68_1155 VGND VPWR sky130_fd_sc_hd__tapvpwrvgnd_1
XFILLER_82_663 VGND VGND VPWR VPWR sky130_fd_sc_hd__decap_3
XFILLER_54_354 VGND VGND VPWR VPWR sky130_fd_sc_hd__fill_2
XFILLER_82_696 VGND VGND VPWR VPWR sky130_fd_sc_hd__decap_3
XFILLER_54_387 VGND VGND VPWR VPWR sky130_fd_sc_hd__decap_3
XFILLER_120_23 VGND VGND VPWR VPWR sky130_fd_sc_hd__decap_3
XTAP_TAPCELL_ROW_81_1322 VGND VPWR sky130_fd_sc_hd__tapvpwrvgnd_1
X_6928_ _7401_/CLK _6928_/D VGND VGND VPWR VPWR _6928_/Q sky130_fd_sc_hd__dfxtp_2
XFILLER_81_195 VGND VGND VPWR VPWR sky130_fd_sc_hd__decap_3
Xfanout22 reset VGND VGND VPWR VPWR _6678_/A sky130_fd_sc_hd__buf_1
XFILLER_120_56 VGND VGND VPWR VPWR sky130_fd_sc_hd__decap_3
Xfanout33 fanout47/X VGND VGND VPWR VPWR _6603_/A sky130_fd_sc_hd__clkdlybuf4s25_1
Xfanout44 fanout46/X VGND VGND VPWR VPWR _6608_/A sky130_fd_sc_hd__buf_2
X_6859_ _7215_/CLK _6859_/D VGND VGND VPWR VPWR _6859_/Q sky130_fd_sc_hd__dfxtp_2
Xfanout55 _6653_/A VGND VGND VPWR VPWR _6680_/A sky130_fd_sc_hd__buf_2
XTAP_TAPCELL_ROW_12_419 VGND VPWR sky130_fd_sc_hd__tapvpwrvgnd_1
Xfanout66 _6350_/A VGND VGND VPWR VPWR _6616_/A sky130_fd_sc_hd__clkdlybuf4s25_1
XFILLER_10_413 VGND VGND VPWR VPWR sky130_fd_sc_hd__decap_3
XFILLER_10_424 VGND VGND VPWR VPWR sky130_fd_sc_hd__fill_2
XFILLER_6_406 VGND VGND VPWR VPWR sky130_fd_sc_hd__decap_3
XFILLER_108_301 VGND VGND VPWR VPWR sky130_fd_sc_hd__decap_3
XTAP_TAPCELL_ROW_79_1295 VGND VPWR sky130_fd_sc_hd__tapvpwrvgnd_1
XFILLER_2_601 VGND VGND VPWR VPWR sky130_fd_sc_hd__fill_2
XFILLER_123_326 VGND VGND VPWR VPWR sky130_fd_sc_hd__decap_3
XFILLER_2_623 VGND VGND VPWR VPWR sky130_fd_sc_hd__decap_3
XFILLER_8_3 VGND VGND VPWR VPWR sky130_fd_sc_hd__decap_3
XFILLER_2_645 VGND VGND VPWR VPWR sky130_fd_sc_hd__decap_3
XFILLER_123_348 VGND VGND VPWR VPWR sky130_fd_sc_hd__decap_3
XTAP_TAPCELL_ROW_92_1462 VGND VPWR sky130_fd_sc_hd__tapvpwrvgnd_1
XFILLER_89_240 VGND VGND VPWR VPWR sky130_fd_sc_hd__decap_3
XFILLER_104_551 VGND VGND VPWR VPWR sky130_fd_sc_hd__decap_3
XFILLER_77_402 VGND VGND VPWR VPWR sky130_fd_sc_hd__decap_3
XFILLER_2_678 VGND VGND VPWR VPWR sky130_fd_sc_hd__decap_3
XFILLER_89_273 VGND VGND VPWR VPWR sky130_fd_sc_hd__decap_3
XFILLER_104_584 VGND VGND VPWR VPWR sky130_fd_sc_hd__decap_3
XFILLER_89_284 VGND VGND VPWR VPWR sky130_fd_sc_hd__decap_3
XFILLER_1_188 VGND VGND VPWR VPWR sky130_fd_sc_hd__decap_3
XFILLER_104_595 VGND VGND VPWR VPWR sky130_fd_sc_hd__decap_3
XFILLER_77_446 VGND VGND VPWR VPWR sky130_fd_sc_hd__fill_2
XFILLER_38_40 VGND VGND VPWR VPWR sky130_fd_sc_hd__fill_2
XFILLER_77_479 VGND VGND VPWR VPWR sky130_fd_sc_hd__decap_3
XFILLER_58_660 VGND VGND VPWR VPWR sky130_fd_sc_hd__decap_3
XFILLER_92_416 VGND VGND VPWR VPWR sky130_fd_sc_hd__decap_3
XFILLER_18_513 VGND VGND VPWR VPWR sky130_fd_sc_hd__decap_3
XFILLER_92_438 VGND VGND VPWR VPWR sky130_fd_sc_hd__decap_3
XFILLER_58_693 VGND VGND VPWR VPWR sky130_fd_sc_hd__decap_3
Xhold1180 _7390_/Q VGND VGND VPWR VPWR _3818_/A1 sky130_fd_sc_hd__dlygate4sd3_1
Xhold1191 _6703_/Q VGND VGND VPWR VPWR _5706_/A1 sky130_fd_sc_hd__dlygate4sd3_1
XFILLER_73_641 VGND VGND VPWR VPWR sky130_fd_sc_hd__decap_3
XFILLER_45_343 VGND VGND VPWR VPWR sky130_fd_sc_hd__fill_2
XFILLER_33_505 VGND VGND VPWR VPWR sky130_fd_sc_hd__decap_3
XFILLER_73_685 VGND VGND VPWR VPWR sky130_fd_sc_hd__decap_3
XFILLER_45_376 VGND VGND VPWR VPWR sky130_fd_sc_hd__fill_2
XFILLER_72_162 VGND VGND VPWR VPWR sky130_fd_sc_hd__decap_3
XFILLER_72_195 VGND VGND VPWR VPWR sky130_fd_sc_hd__fill_1
XFILLER_60_368 VGND VGND VPWR VPWR sky130_fd_sc_hd__decap_3
XPHY_EDGE_ROW_109_Left_233 VGND VGND VPWR VPWR sky130_fd_sc_hd__decap_3
XFILLER_13_240 VGND VGND VPWR VPWR sky130_fd_sc_hd__decap_3
XFILLER_9_222 VGND VGND VPWR VPWR sky130_fd_sc_hd__fill_2
XFILLER_13_284 VGND VGND VPWR VPWR sky130_fd_sc_hd__decap_3
XTAP_TAPCELL_ROW_101_1580 VGND VPWR sky130_fd_sc_hd__tapvpwrvgnd_1
XFILLER_9_266 VGND VGND VPWR VPWR sky130_fd_sc_hd__decap_3
Xclkload14 _7352_/CLK VGND VGND VPWR VPWR clkload14/Y sky130_fd_sc_hd__inv_4
Xclkload25 _7399_/CLK VGND VGND VPWR VPWR clkload25/X sky130_fd_sc_hd__clkbuf_16
XFILLER_114_326 VGND VGND VPWR VPWR sky130_fd_sc_hd__decap_3
XFILLER_5_494 VGND VGND VPWR VPWR sky130_fd_sc_hd__fill_1
XFILLER_114_348 VGND VGND VPWR VPWR sky130_fd_sc_hd__decap_3
X_4210_ _4095_/A _4210_/B VGND VGND VPWR VPWR _4210_/X sky130_fd_sc_hd__and2b_2
XPHY_EDGE_ROW_118_Left_242 VGND VGND VPWR VPWR sky130_fd_sc_hd__decap_3
X_5190_ _5190_/A _5200_/B VGND VGND VPWR VPWR _7233_/D sky130_fd_sc_hd__and2_2
XFILLER_96_722 VGND VGND VPWR VPWR sky130_fd_sc_hd__decap_3
X_4141_ _4141_/A _4141_/B VGND VGND VPWR VPWR _4142_/B sky130_fd_sc_hd__nor2_2
XFILLER_68_424 VGND VGND VPWR VPWR sky130_fd_sc_hd__decap_3
XFILLER_110_521 VGND VGND VPWR VPWR sky130_fd_sc_hd__decap_3
XFILLER_95_254 VGND VGND VPWR VPWR sky130_fd_sc_hd__decap_3
XFILLER_110_554 VGND VGND VPWR VPWR sky130_fd_sc_hd__decap_3
X_4072_ _7243_/Q _4430_/A2 _4430_/B1 _7179_/Q _4071_/X VGND VGND VPWR VPWR _4072_/X
+ sky130_fd_sc_hd__a221o_2
XFILLER_83_405 VGND VGND VPWR VPWR sky130_fd_sc_hd__fill_1
XFILLER_56_619 VGND VGND VPWR VPWR sky130_fd_sc_hd__decap_3
XFILLER_49_671 VGND VGND VPWR VPWR sky130_fd_sc_hd__fill_1
XFILLER_110_587 VGND VGND VPWR VPWR sky130_fd_sc_hd__fill_1
XFILLER_83_427 VGND VGND VPWR VPWR sky130_fd_sc_hd__decap_3
XFILLER_49_682 VGND VGND VPWR VPWR sky130_fd_sc_hd__decap_3
XFILLER_110_598 VGND VGND VPWR VPWR sky130_fd_sc_hd__decap_3
XFILLER_36_321 VGND VGND VPWR VPWR sky130_fd_sc_hd__decap_3
XFILLER_64_663 VGND VGND VPWR VPWR sky130_fd_sc_hd__decap_3
XFILLER_36_365 VGND VGND VPWR VPWR sky130_fd_sc_hd__decap_3
XTAP_TAPCELL_ROW_47_872 VGND VPWR sky130_fd_sc_hd__tapvpwrvgnd_1
XFILLER_24_516 VGND VGND VPWR VPWR sky130_fd_sc_hd__decap_3
XTAP_TAPCELL_ROW_47_883 VGND VPWR sky130_fd_sc_hd__tapvpwrvgnd_1
XFILLER_64_696 VGND VGND VPWR VPWR sky130_fd_sc_hd__decap_3
XFILLER_63_184 VGND VGND VPWR VPWR sky130_fd_sc_hd__decap_3
X_4974_ _6993_/Q _4983_/B VGND VGND VPWR VPWR _4975_/B sky130_fd_sc_hd__xor2_2
X_3925_ _6687_/Q _3925_/A2 _3925_/B1 _6865_/Q VGND VGND VPWR VPWR _3925_/X sky130_fd_sc_hd__a22o_2
X_6713_ _7403_/CLK _6713_/D VGND VGND VPWR VPWR _6713_/Q sky130_fd_sc_hd__dfxtp_2
XFILLER_20_722 VGND VGND VPWR VPWR sky130_fd_sc_hd__decap_3
XTAP_TAPCELL_ROW_63_1085 VGND VPWR sky130_fd_sc_hd__tapvpwrvgnd_1
X_6644_ _6644_/A VGND VGND VPWR VPWR _6644_/Y sky130_fd_sc_hd__inv_2
X_3856_ _3845_/X _3855_/X _3991_/A VGND VGND VPWR VPWR _3856_/X sky130_fd_sc_hd__o21a_2
Xclkload8 clkload8/A VGND VGND VPWR VPWR clkload8/X sky130_fd_sc_hd__clkbuf_1
XFILLER_118_610 VGND VGND VPWR VPWR sky130_fd_sc_hd__decap_3
X_6575_ _6612_/A VGND VGND VPWR VPWR _6575_/Y sky130_fd_sc_hd__inv_2
X_3787_ _6739_/Q _3893_/A2 _3850_/B1 _6745_/Q _3786_/X VGND VGND VPWR VPWR _3787_/X
+ sky130_fd_sc_hd__a221o_2
XFILLER_118_643 VGND VGND VPWR VPWR sky130_fd_sc_hd__fill_1
XFILLER_118_654 VGND VGND VPWR VPWR sky130_fd_sc_hd__decap_3
XFILLER_118_687 VGND VGND VPWR VPWR sky130_fd_sc_hd__decap_3
XFILLER_117_164 VGND VGND VPWR VPWR sky130_fd_sc_hd__decap_3
XFILLER_117_175 VGND VGND VPWR VPWR sky130_fd_sc_hd__fill_2
Xoutput530 _6996_/Q VGND VGND VPWR VPWR pc_out[19] sky130_fd_sc_hd__clkdlybuf4s25_1
XFILLER_105_337 VGND VGND VPWR VPWR sky130_fd_sc_hd__decap_3
Xoutput541 _7006_/Q VGND VGND VPWR VPWR pc_out[29] sky130_fd_sc_hd__clkdlybuf4s25_1
X_4408_ _7024_/Q _4431_/A2 _4404_/X _4407_/X VGND VGND VPWR VPWR _4409_/B sky130_fd_sc_hd__a211o_2
X_5388_ _5388_/A0 _4913_/X _5398_/S VGND VGND VPWR VPWR _7139_/D sky130_fd_sc_hd__mux2_2
XFILLER_87_700 VGND VGND VPWR VPWR sky130_fd_sc_hd__decap_3
XFILLER_59_402 VGND VGND VPWR VPWR sky130_fd_sc_hd__decap_3
XFILLER_99_582 VGND VGND VPWR VPWR sky130_fd_sc_hd__decap_3
X_7127_ _7325_/CLK _7127_/D _6407_/Y VGND VGND VPWR VPWR _7127_/Q sky130_fd_sc_hd__dfrtp_2
X_4339_ _7287_/Q _4534_/S _4348_/A2 _7159_/Q VGND VGND VPWR VPWR _4339_/X sky130_fd_sc_hd__a22o_2
XFILLER_86_221 VGND VGND VPWR VPWR sky130_fd_sc_hd__decap_3
XFILLER_115_34 VGND VGND VPWR VPWR sky130_fd_sc_hd__decap_3
XFILLER_101_543 VGND VGND VPWR VPWR sky130_fd_sc_hd__decap_3
X_7058_ _7279_/CLK _7058_/D _6338_/Y VGND VGND VPWR VPWR _7058_/Q sky130_fd_sc_hd__dfstp_2
XFILLER_59_479 VGND VGND VPWR VPWR sky130_fd_sc_hd__decap_3
XFILLER_115_78 VGND VGND VPWR VPWR sky130_fd_sc_hd__decap_3
XFILLER_86_265 VGND VGND VPWR VPWR sky130_fd_sc_hd__decap_3
XFILLER_101_576 VGND VGND VPWR VPWR sky130_fd_sc_hd__decap_3
XFILLER_39_181 VGND VGND VPWR VPWR sky130_fd_sc_hd__fill_1
XFILLER_55_641 VGND VGND VPWR VPWR sky130_fd_sc_hd__decap_3
XFILLER_27_343 VGND VGND VPWR VPWR sky130_fd_sc_hd__decap_3
XFILLER_15_505 VGND VGND VPWR VPWR sky130_fd_sc_hd__decap_3
XFILLER_55_685 VGND VGND VPWR VPWR sky130_fd_sc_hd__decap_3
XFILLER_27_376 VGND VGND VPWR VPWR sky130_fd_sc_hd__decap_3
XFILLER_70_622 VGND VGND VPWR VPWR sky130_fd_sc_hd__decap_3
XFILLER_15_538 VGND VGND VPWR VPWR sky130_fd_sc_hd__decap_3
XFILLER_54_184 VGND VGND VPWR VPWR sky130_fd_sc_hd__decap_3
XFILLER_70_666 VGND VGND VPWR VPWR sky130_fd_sc_hd__decap_3
XFILLER_30_508 VGND VGND VPWR VPWR sky130_fd_sc_hd__decap_3
XFILLER_11_700 VGND VGND VPWR VPWR sky130_fd_sc_hd__decap_3
XFILLER_70_699 VGND VGND VPWR VPWR sky130_fd_sc_hd__fill_1
XTAP_TAPCELL_ROW_25_588 VGND VPWR sky130_fd_sc_hd__tapvpwrvgnd_1
XFILLER_23_571 VGND VGND VPWR VPWR sky130_fd_sc_hd__decap_3
XFILLER_50_390 VGND VGND VPWR VPWR sky130_fd_sc_hd__fill_2
XFILLER_7_715 VGND VGND VPWR VPWR sky130_fd_sc_hd__decap_3
XFILLER_6_203 VGND VGND VPWR VPWR sky130_fd_sc_hd__decap_3
XFILLER_109_632 VGND VGND VPWR VPWR sky130_fd_sc_hd__decap_3
XFILLER_6_247 VGND VGND VPWR VPWR sky130_fd_sc_hd__decap_3
XFILLER_10_298 VGND VGND VPWR VPWR sky130_fd_sc_hd__decap_3
XFILLER_40_52 VGND VGND VPWR VPWR sky130_fd_sc_hd__decap_3
XFILLER_109_665 VGND VGND VPWR VPWR sky130_fd_sc_hd__decap_3
XFILLER_109_676 VGND VGND VPWR VPWR sky130_fd_sc_hd__decap_3
XFILLER_40_85 VGND VGND VPWR VPWR sky130_fd_sc_hd__decap_3
XFILLER_123_101 VGND VGND VPWR VPWR sky130_fd_sc_hd__decap_3
XFILLER_123_134 VGND VGND VPWR VPWR sky130_fd_sc_hd__decap_3
XFILLER_123_167 VGND VGND VPWR VPWR sky130_fd_sc_hd__fill_1
XFILLER_78_722 VGND VGND VPWR VPWR sky130_fd_sc_hd__decap_3
XFILLER_2_475 VGND VGND VPWR VPWR sky130_fd_sc_hd__fill_1
XFILLER_111_329 VGND VGND VPWR VPWR sky130_fd_sc_hd__decap_3
XFILLER_104_392 VGND VGND VPWR VPWR sky130_fd_sc_hd__decap_3
XFILLER_93_703 VGND VGND VPWR VPWR sky130_fd_sc_hd__decap_3
XFILLER_38_619 VGND VGND VPWR VPWR sky130_fd_sc_hd__decap_3
XFILLER_77_265 VGND VGND VPWR VPWR sky130_fd_sc_hd__decap_3
XFILLER_65_416 VGND VGND VPWR VPWR sky130_fd_sc_hd__decap_3
XFILLER_1_24 VGND VGND VPWR VPWR sky130_fd_sc_hd__fill_2
XFILLER_77_287 VGND VGND VPWR VPWR sky130_fd_sc_hd__decap_3
XFILLER_92_235 VGND VGND VPWR VPWR sky130_fd_sc_hd__decap_3
XFILLER_65_449 VGND VGND VPWR VPWR sky130_fd_sc_hd__decap_3
XFILLER_46_641 VGND VGND VPWR VPWR sky130_fd_sc_hd__decap_3
XFILLER_65_60 VGND VGND VPWR VPWR sky130_fd_sc_hd__decap_3
XFILLER_92_268 VGND VGND VPWR VPWR sky130_fd_sc_hd__decap_3
XFILLER_46_663 VGND VGND VPWR VPWR sky130_fd_sc_hd__decap_3
XFILLER_18_365 VGND VGND VPWR VPWR sky130_fd_sc_hd__decap_3
XFILLER_61_611 VGND VGND VPWR VPWR sky130_fd_sc_hd__decap_3
XFILLER_73_482 VGND VGND VPWR VPWR sky130_fd_sc_hd__decap_3
XFILLER_46_696 VGND VGND VPWR VPWR sky130_fd_sc_hd__decap_3
XFILLER_33_313 VGND VGND VPWR VPWR sky130_fd_sc_hd__decap_3
XFILLER_45_184 VGND VGND VPWR VPWR sky130_fd_sc_hd__decap_3
XFILLER_61_644 VGND VGND VPWR VPWR sky130_fd_sc_hd__decap_3
XTAP_TAPCELL_ROW_44_842 VGND VPWR sky130_fd_sc_hd__tapvpwrvgnd_1
XFILLER_60_121 VGND VGND VPWR VPWR sky130_fd_sc_hd__decap_3
XFILLER_33_346 VGND VGND VPWR VPWR sky130_fd_sc_hd__decap_3
XFILLER_61_688 VGND VGND VPWR VPWR sky130_fd_sc_hd__decap_3
XFILLER_14_582 VGND VGND VPWR VPWR sky130_fd_sc_hd__decap_3
X_3710_ hold969/X _4799_/A _3709_/X VGND VGND VPWR VPWR _7399_/D sky130_fd_sc_hd__o21a_2
X_4690_ _7005_/Q _4690_/B VGND VGND VPWR VPWR _4757_/A sky130_fd_sc_hd__and2_2
X_6360_ _6684_/A VGND VGND VPWR VPWR _6360_/Y sky130_fd_sc_hd__inv_2
XFILLER_60_3 VGND VGND VPWR VPWR sky130_fd_sc_hd__decap_3
X_3572_ _4295_/B _3607_/B VGND VGND VPWR VPWR _4292_/A sky130_fd_sc_hd__xnor2_2
XFILLER_115_635 VGND VGND VPWR VPWR sky130_fd_sc_hd__decap_3
X_6291_ _6602_/A VGND VGND VPWR VPWR _6291_/Y sky130_fd_sc_hd__inv_2
XFILLER_115_668 VGND VGND VPWR VPWR sky130_fd_sc_hd__decap_3
XFILLER_115_679 VGND VGND VPWR VPWR sky130_fd_sc_hd__decap_3
XFILLER_69_700 VGND VGND VPWR VPWR sky130_fd_sc_hd__decap_3
XFILLER_114_167 VGND VGND VPWR VPWR sky130_fd_sc_hd__decap_3
X_5173_ _5173_/A _5200_/B VGND VGND VPWR VPWR _7241_/D sky130_fd_sc_hd__and2_2
XFILLER_123_690 VGND VGND VPWR VPWR sky130_fd_sc_hd__fill_2
X_4124_ _4117_/Y _4124_/B VGND VGND VPWR VPWR _4126_/A sky130_fd_sc_hd__and2b_2
XFILLER_96_563 VGND VGND VPWR VPWR sky130_fd_sc_hd__decap_3
XFILLER_68_265 VGND VGND VPWR VPWR sky130_fd_sc_hd__decap_3
XFILLER_56_405 VGND VGND VPWR VPWR sky130_fd_sc_hd__decap_3
XFILLER_84_725 VGND VGND VPWR VPWR sky130_fd_sc_hd__decap_3
XFILLER_28_107 VGND VGND VPWR VPWR sky130_fd_sc_hd__decap_3
XFILLER_110_362 VGND VGND VPWR VPWR sky130_fd_sc_hd__fill_2
XFILLER_83_213 VGND VGND VPWR VPWR sky130_fd_sc_hd__decap_3
XFILLER_56_427 VGND VGND VPWR VPWR sky130_fd_sc_hd__decap_3
XFILLER_28_118 VGND VGND VPWR VPWR sky130_fd_sc_hd__decap_3
X_4055_ _4055_/A _4658_/A VGND VGND VPWR VPWR _4720_/A sky130_fd_sc_hd__nor2b_2
XFILLER_83_246 VGND VGND VPWR VPWR sky130_fd_sc_hd__decap_3
XFILLER_37_641 VGND VGND VPWR VPWR sky130_fd_sc_hd__decap_3
XFILLER_83_279 VGND VGND VPWR VPWR sky130_fd_sc_hd__fill_1
XFILLER_37_685 VGND VGND VPWR VPWR sky130_fd_sc_hd__decap_3
XTAP_TAPCELL_ROW_65_1114 VGND VPWR sky130_fd_sc_hd__tapvpwrvgnd_1
XFILLER_52_622 VGND VGND VPWR VPWR sky130_fd_sc_hd__decap_3
XFILLER_36_173 VGND VGND VPWR VPWR sky130_fd_sc_hd__decap_3
XFILLER_36_184 VGND VGND VPWR VPWR sky130_fd_sc_hd__decap_3
XFILLER_91_290 VGND VGND VPWR VPWR sky130_fd_sc_hd__decap_3
XFILLER_52_666 VGND VGND VPWR VPWR sky130_fd_sc_hd__decap_3
XFILLER_24_357 VGND VGND VPWR VPWR sky130_fd_sc_hd__decap_3
XFILLER_24_368 VGND VGND VPWR VPWR sky130_fd_sc_hd__decap_3
X_4957_ _4982_/B _5009_/A _6992_/Q VGND VGND VPWR VPWR _4983_/B sky130_fd_sc_hd__o21ai_2
XFILLER_51_165 VGND VGND VPWR VPWR sky130_fd_sc_hd__decap_3
XFILLER_52_699 VGND VGND VPWR VPWR sky130_fd_sc_hd__fill_1
XTAP_TAPCELL_ROW_22_547 VGND VPWR sky130_fd_sc_hd__tapvpwrvgnd_1
X_3908_ _3728_/B _3907_/X _3991_/A VGND VGND VPWR VPWR _3908_/X sky130_fd_sc_hd__o21a_2
X_4888_ _4888_/A _4888_/B VGND VGND VPWR VPWR _4889_/B sky130_fd_sc_hd__or2_2
XTAP_TAPCELL_ROW_22_558 VGND VPWR sky130_fd_sc_hd__tapvpwrvgnd_1
XFILLER_20_563 VGND VGND VPWR VPWR sky130_fd_sc_hd__decap_3
X_3839_ _3746_/X _3836_/X _3838_/X _3733_/X VGND VGND VPWR VPWR _3845_/A sky130_fd_sc_hd__a22o_2
X_6627_ _6630_/A VGND VGND VPWR VPWR _6627_/Y sky130_fd_sc_hd__inv_2
X_6558_ _6558_/A VGND VGND VPWR VPWR _6558_/Y sky130_fd_sc_hd__inv_2
XFILLER_4_707 VGND VGND VPWR VPWR sky130_fd_sc_hd__decap_3
XFILLER_106_613 VGND VGND VPWR VPWR sky130_fd_sc_hd__decap_3
XFILLER_118_473 VGND VGND VPWR VPWR sky130_fd_sc_hd__decap_3
XFILLER_3_228 VGND VGND VPWR VPWR sky130_fd_sc_hd__decap_3
XFILLER_118_495 VGND VGND VPWR VPWR sky130_fd_sc_hd__decap_3
XTAP_TAPCELL_ROW_76_1254 VGND VPWR sky130_fd_sc_hd__tapvpwrvgnd_1
X_6489_ _6649_/A VGND VGND VPWR VPWR _6489_/Y sky130_fd_sc_hd__inv_2
XFILLER_10_44 VGND VGND VPWR VPWR sky130_fd_sc_hd__fill_1
XFILLER_106_657 VGND VGND VPWR VPWR sky130_fd_sc_hd__decap_3
XFILLER_105_134 VGND VGND VPWR VPWR sky130_fd_sc_hd__fill_1
XFILLER_105_156 VGND VGND VPWR VPWR sky130_fd_sc_hd__fill_1
XFILLER_105_167 VGND VGND VPWR VPWR sky130_fd_sc_hd__fill_1
XFILLER_86_15 VGND VGND VPWR VPWR sky130_fd_sc_hd__decap_3
XFILLER_121_638 VGND VGND VPWR VPWR sky130_fd_sc_hd__decap_3
XFILLER_105_189 VGND VGND VPWR VPWR sky130_fd_sc_hd__decap_3
XFILLER_59_210 VGND VGND VPWR VPWR sky130_fd_sc_hd__decap_3
XFILLER_114_690 VGND VGND VPWR VPWR sky130_fd_sc_hd__decap_3
XFILLER_75_703 VGND VGND VPWR VPWR sky130_fd_sc_hd__decap_3
XFILLER_59_265 VGND VGND VPWR VPWR sky130_fd_sc_hd__fill_2
XFILLER_47_405 VGND VGND VPWR VPWR sky130_fd_sc_hd__decap_3
XFILLER_87_585 VGND VGND VPWR VPWR sky130_fd_sc_hd__decap_3
XFILLER_47_427 VGND VGND VPWR VPWR sky130_fd_sc_hd__decap_3
XFILLER_59_298 VGND VGND VPWR VPWR sky130_fd_sc_hd__decap_3
XFILLER_74_224 VGND VGND VPWR VPWR sky130_fd_sc_hd__decap_3
XFILLER_47_449 VGND VGND VPWR VPWR sky130_fd_sc_hd__decap_3
Xclkbuf_leaf_39_clk clkbuf_leaf_1_clk/A VGND VGND VPWR VPWR clkload6/A sky130_fd_sc_hd__clkbuf_16
XFILLER_74_268 VGND VGND VPWR VPWR sky130_fd_sc_hd__decap_3
XFILLER_90_728 VGND VGND VPWR VPWR sky130_fd_sc_hd__decap_3
XFILLER_28_663 VGND VGND VPWR VPWR sky130_fd_sc_hd__decap_3
XFILLER_43_611 VGND VGND VPWR VPWR sky130_fd_sc_hd__decap_3
XTAP_TAPCELL_ROW_2_294 VGND VPWR sky130_fd_sc_hd__tapvpwrvgnd_1
XFILLER_28_696 VGND VGND VPWR VPWR sky130_fd_sc_hd__decap_3
XTAP_TAPCELL_ROW_87_1394 VGND VPWR sky130_fd_sc_hd__tapvpwrvgnd_1
XFILLER_15_324 VGND VGND VPWR VPWR sky130_fd_sc_hd__decap_3
XFILLER_43_644 VGND VGND VPWR VPWR sky130_fd_sc_hd__decap_3
XFILLER_15_346 VGND VGND VPWR VPWR sky130_fd_sc_hd__decap_3
XFILLER_42_154 VGND VGND VPWR VPWR sky130_fd_sc_hd__decap_3
XTAP_TAPCELL_ROW_41_801 VGND VPWR sky130_fd_sc_hd__tapvpwrvgnd_1
XFILLER_70_474 VGND VGND VPWR VPWR sky130_fd_sc_hd__fill_2
XFILLER_43_688 VGND VGND VPWR VPWR sky130_fd_sc_hd__decap_3
XFILLER_42_176 VGND VGND VPWR VPWR sky130_fd_sc_hd__decap_3
XFILLER_30_349 VGND VGND VPWR VPWR sky130_fd_sc_hd__decap_3
XFILLER_23_390 VGND VGND VPWR VPWR sky130_fd_sc_hd__fill_2
XFILLER_11_541 VGND VGND VPWR VPWR sky130_fd_sc_hd__decap_3
XFILLER_7_512 VGND VGND VPWR VPWR sky130_fd_sc_hd__decap_3
XFILLER_11_585 VGND VGND VPWR VPWR sky130_fd_sc_hd__decap_3
XFILLER_7_545 VGND VGND VPWR VPWR sky130_fd_sc_hd__decap_3
XFILLER_7_567 VGND VGND VPWR VPWR sky130_fd_sc_hd__decap_3
XFILLER_97_305 VGND VGND VPWR VPWR sky130_fd_sc_hd__decap_3
XFILLER_112_616 VGND VGND VPWR VPWR sky130_fd_sc_hd__decap_3
XFILLER_97_349 VGND VGND VPWR VPWR sky130_fd_sc_hd__decap_3
XFILLER_78_563 VGND VGND VPWR VPWR sky130_fd_sc_hd__decap_3
XTAP_TAPCELL_ROW_49_901 VGND VPWR sky130_fd_sc_hd__tapvpwrvgnd_1
XFILLER_38_405 VGND VGND VPWR VPWR sky130_fd_sc_hd__decap_3
XFILLER_120_660 VGND VGND VPWR VPWR sky130_fd_sc_hd__decap_3
XFILLER_78_585 VGND VGND VPWR VPWR sky130_fd_sc_hd__decap_3
XFILLER_66_725 VGND VGND VPWR VPWR sky130_fd_sc_hd__decap_3
XFILLER_65_213 VGND VGND VPWR VPWR sky130_fd_sc_hd__decap_3
XFILLER_120_693 VGND VGND VPWR VPWR sky130_fd_sc_hd__decap_3
XFILLER_38_449 VGND VGND VPWR VPWR sky130_fd_sc_hd__decap_3
XFILLER_65_246 VGND VGND VPWR VPWR sky130_fd_sc_hd__decap_3
XFILLER_19_641 VGND VGND VPWR VPWR sky130_fd_sc_hd__decap_3
XFILLER_81_706 VGND VGND VPWR VPWR sky130_fd_sc_hd__decap_3
XFILLER_93_588 VGND VGND VPWR VPWR sky130_fd_sc_hd__decap_3
XFILLER_65_279 VGND VGND VPWR VPWR sky130_fd_sc_hd__fill_1
XFILLER_19_685 VGND VGND VPWR VPWR sky130_fd_sc_hd__decap_3
XFILLER_34_622 VGND VGND VPWR VPWR sky130_fd_sc_hd__decap_3
XFILLER_80_249 VGND VGND VPWR VPWR sky130_fd_sc_hd__decap_3
XFILLER_18_195 VGND VGND VPWR VPWR sky130_fd_sc_hd__fill_1
XFILLER_73_290 VGND VGND VPWR VPWR sky130_fd_sc_hd__decap_3
XFILLER_61_430 VGND VGND VPWR VPWR sky130_fd_sc_hd__decap_3
XFILLER_61_452 VGND VGND VPWR VPWR sky130_fd_sc_hd__decap_3
XFILLER_34_666 VGND VGND VPWR VPWR sky130_fd_sc_hd__decap_3
X_4811_ _4652_/B _4811_/B _4811_/C VGND VGND VPWR VPWR _4811_/X sky130_fd_sc_hd__and3b_2
XFILLER_92_91 VGND VGND VPWR VPWR sky130_fd_sc_hd__decap_3
XFILLER_34_699 VGND VGND VPWR VPWR sky130_fd_sc_hd__fill_1
XFILLER_21_327 VGND VGND VPWR VPWR sky130_fd_sc_hd__decap_3
X_4742_ _4069_/Y _4081_/X _4454_/X _4969_/B VGND VGND VPWR VPWR _4742_/Y sky130_fd_sc_hd__o211ai_2
XTAP_TAPCELL_ROW_60_1044 VGND VPWR sky130_fd_sc_hd__tapvpwrvgnd_1
X_4673_ _4982_/B _4673_/B VGND VGND VPWR VPWR _4680_/A sky130_fd_sc_hd__or2_2
X_6412_ _6644_/A VGND VGND VPWR VPWR _6412_/Y sky130_fd_sc_hd__inv_2
X_3624_ _5072_/A _3600_/A _4614_/C _5033_/B2 VGND VGND VPWR VPWR _3624_/X sky130_fd_sc_hd__a22o_2
X_7392_ _7392_/CLK _7392_/D _6672_/Y VGND VGND VPWR VPWR _7392_/Q sky130_fd_sc_hd__dfrtp_2
X_6343_ _6658_/A VGND VGND VPWR VPWR _6343_/Y sky130_fd_sc_hd__inv_2
X_3555_ _7285_/Q _4532_/S _3366_/X _7157_/Q VGND VGND VPWR VPWR _3556_/C sky130_fd_sc_hd__a22o_2
XFILLER_115_421 VGND VGND VPWR VPWR sky130_fd_sc_hd__decap_3
XTAP_TAPCELL_ROW_112_1719 VGND VPWR sky130_fd_sc_hd__tapvpwrvgnd_1
X_6274_ _6275_/A VGND VGND VPWR VPWR _6274_/Y sky130_fd_sc_hd__inv_2
XFILLER_88_305 VGND VGND VPWR VPWR sky130_fd_sc_hd__decap_3
XFILLER_0_209 VGND VGND VPWR VPWR sky130_fd_sc_hd__decap_3
X_3486_ _3502_/A _3502_/B _3485_/C VGND VGND VPWR VPWR _5144_/B sky130_fd_sc_hd__o21ai_2
XFILLER_103_638 VGND VGND VPWR VPWR sky130_fd_sc_hd__decap_3
X_5225_ _5225_/A _5225_/B VGND VGND VPWR VPWR _7216_/D sky130_fd_sc_hd__and2_2
XFILLER_88_338 VGND VGND VPWR VPWR sky130_fd_sc_hd__decap_3
XFILLER_69_530 VGND VGND VPWR VPWR sky130_fd_sc_hd__fill_2
XFILLER_102_126 VGND VGND VPWR VPWR sky130_fd_sc_hd__decap_3
XFILLER_57_703 VGND VGND VPWR VPWR sky130_fd_sc_hd__decap_3
X_5156_ _7010_/D _5155_/X _5156_/S VGND VGND VPWR VPWR _5156_/X sky130_fd_sc_hd__mux2_2
XTAP_TAPCELL_ROW_71_1184 VGND VPWR sky130_fd_sc_hd__tapvpwrvgnd_1
XFILLER_84_500 VGND VGND VPWR VPWR sky130_fd_sc_hd__decap_3
XFILLER_111_671 VGND VGND VPWR VPWR sky130_fd_sc_hd__fill_1
XTAP_TAPCELL_ROW_71_1195 VGND VPWR sky130_fd_sc_hd__tapvpwrvgnd_1
XFILLER_111_682 VGND VGND VPWR VPWR sky130_fd_sc_hd__decap_3
X_4107_ _7301_/Q _4979_/S _4434_/A2 _7109_/Q _4106_/X VGND VGND VPWR VPWR _4107_/X
+ sky130_fd_sc_hd__a221o_2
XFILLER_56_235 VGND VGND VPWR VPWR sky130_fd_sc_hd__decap_3
XFILLER_29_449 VGND VGND VPWR VPWR sky130_fd_sc_hd__decap_3
X_5087_ _5101_/B _5100_/B _5086_/A _4365_/X VGND VGND VPWR VPWR _5087_/Y sky130_fd_sc_hd__a211oi_2
X_4038_ _4039_/A _4458_/A VGND VGND VPWR VPWR _4608_/B sky130_fd_sc_hd__nor2_2
XFILLER_72_728 VGND VGND VPWR VPWR sky130_fd_sc_hd__decap_3
XTAP_TAPCELL_ROW_27_617 VGND VPWR sky130_fd_sc_hd__tapvpwrvgnd_1
XFILLER_25_600 VGND VGND VPWR VPWR sky130_fd_sc_hd__decap_3
XFILLER_37_471 VGND VGND VPWR VPWR sky130_fd_sc_hd__decap_3
XFILLER_112_35 VGND VGND VPWR VPWR sky130_fd_sc_hd__decap_3
XFILLER_37_482 VGND VGND VPWR VPWR sky130_fd_sc_hd__decap_3
XFILLER_71_249 VGND VGND VPWR VPWR sky130_fd_sc_hd__decap_3
XFILLER_25_644 VGND VGND VPWR VPWR sky130_fd_sc_hd__decap_3
XFILLER_112_68 VGND VGND VPWR VPWR sky130_fd_sc_hd__decap_3
XFILLER_72_17 VGND VGND VPWR VPWR sky130_fd_sc_hd__decap_3
XFILLER_52_430 VGND VGND VPWR VPWR sky130_fd_sc_hd__fill_1
XFILLER_52_452 VGND VGND VPWR VPWR sky130_fd_sc_hd__decap_3
XFILLER_25_688 VGND VGND VPWR VPWR sky130_fd_sc_hd__decap_3
XFILLER_24_165 VGND VGND VPWR VPWR sky130_fd_sc_hd__decap_3
XFILLER_40_625 VGND VGND VPWR VPWR sky130_fd_sc_hd__decap_3
XFILLER_52_496 VGND VGND VPWR VPWR sky130_fd_sc_hd__fill_2
XFILLER_12_349 VGND VGND VPWR VPWR sky130_fd_sc_hd__decap_3
XFILLER_40_669 VGND VGND VPWR VPWR sky130_fd_sc_hd__decap_3
XFILLER_20_360 VGND VGND VPWR VPWR sky130_fd_sc_hd__decap_3
XFILLER_20_382 VGND VGND VPWR VPWR sky130_fd_sc_hd__fill_1
XFILLER_21_54 VGND VGND VPWR VPWR sky130_fd_sc_hd__fill_2
XFILLER_4_548 VGND VGND VPWR VPWR sky130_fd_sc_hd__decap_3
XFILLER_121_402 VGND VGND VPWR VPWR sky130_fd_sc_hd__fill_1
XFILLER_0_710 VGND VGND VPWR VPWR sky130_fd_sc_hd__decap_3
XTAP_TAPCELL_ROW_7_353 VGND VPWR sky130_fd_sc_hd__tapvpwrvgnd_1
XTAP_TAPCELL_ROW_7_364 VGND VPWR sky130_fd_sc_hd__tapvpwrvgnd_1
XFILLER_121_479 VGND VGND VPWR VPWR sky130_fd_sc_hd__decap_3
XFILLER_102_660 VGND VGND VPWR VPWR sky130_fd_sc_hd__decap_3
XFILLER_48_725 VGND VGND VPWR VPWR sky130_fd_sc_hd__decap_3
XTAP_TAPCELL_ROW_89_1423 VGND VPWR sky130_fd_sc_hd__tapvpwrvgnd_1
XFILLER_75_533 VGND VGND VPWR VPWR sky130_fd_sc_hd__decap_3
XFILLER_102_693 VGND VGND VPWR VPWR sky130_fd_sc_hd__decap_3
XFILLER_87_393 VGND VGND VPWR VPWR sky130_fd_sc_hd__decap_3
XFILLER_47_235 VGND VGND VPWR VPWR sky130_fd_sc_hd__fill_2
XFILLER_101_192 VGND VGND VPWR VPWR sky130_fd_sc_hd__fill_1
XFILLER_63_706 VGND VGND VPWR VPWR sky130_fd_sc_hd__decap_3
XFILLER_90_503 VGND VGND VPWR VPWR sky130_fd_sc_hd__decap_3
XFILLER_75_588 VGND VGND VPWR VPWR sky130_fd_sc_hd__decap_3
XFILLER_47_279 VGND VGND VPWR VPWR sky130_fd_sc_hd__fill_1
XFILLER_28_471 VGND VGND VPWR VPWR sky130_fd_sc_hd__decap_3
XFILLER_16_622 VGND VGND VPWR VPWR sky130_fd_sc_hd__decap_3
XFILLER_62_238 VGND VGND VPWR VPWR sky130_fd_sc_hd__decap_3
XFILLER_90_569 VGND VGND VPWR VPWR sky130_fd_sc_hd__decap_3
XFILLER_16_666 VGND VGND VPWR VPWR sky130_fd_sc_hd__decap_3
XFILLER_43_452 VGND VGND VPWR VPWR sky130_fd_sc_hd__decap_3
XFILLER_31_603 VGND VGND VPWR VPWR sky130_fd_sc_hd__decap_3
XTAP_TAPCELL_ROW_54_970 VGND VPWR sky130_fd_sc_hd__tapvpwrvgnd_1
XFILLER_16_699 VGND VGND VPWR VPWR sky130_fd_sc_hd__fill_1
XFILLER_31_647 VGND VGND VPWR VPWR sky130_fd_sc_hd__decap_3
XFILLER_70_293 VGND VGND VPWR VPWR sky130_fd_sc_hd__decap_3
XFILLER_15_198 VGND VGND VPWR VPWR sky130_fd_sc_hd__fill_2
XFILLER_30_135 VGND VGND VPWR VPWR sky130_fd_sc_hd__decap_3
XFILLER_7_34 VGND VGND VPWR VPWR sky130_fd_sc_hd__decap_3
XFILLER_7_320 VGND VGND VPWR VPWR sky130_fd_sc_hd__decap_3
XFILLER_11_393 VGND VGND VPWR VPWR sky130_fd_sc_hd__decap_3
XFILLER_109_281 VGND VGND VPWR VPWR sky130_fd_sc_hd__decap_3
X_3340_ _3340_/A _3340_/B _3340_/C VGND VGND VPWR VPWR _5640_/B sky130_fd_sc_hd__and3_2
XFILLER_98_625 VGND VGND VPWR VPWR sky130_fd_sc_hd__decap_3
XFILLER_97_102 VGND VGND VPWR VPWR sky130_fd_sc_hd__fill_1
XFILLER_112_402 VGND VGND VPWR VPWR sky130_fd_sc_hd__decap_3
XFILLER_97_113 VGND VGND VPWR VPWR sky130_fd_sc_hd__fill_1
XFILLER_3_570 VGND VGND VPWR VPWR sky130_fd_sc_hd__decap_3
XFILLER_112_424 VGND VGND VPWR VPWR sky130_fd_sc_hd__decap_3
XFILLER_98_669 VGND VGND VPWR VPWR sky130_fd_sc_hd__decap_3
XFILLER_112_457 VGND VGND VPWR VPWR sky130_fd_sc_hd__fill_1
X_5010_ _5010_/A _5662_/A _5010_/C _5010_/D VGND VGND VPWR VPWR _5010_/X sky130_fd_sc_hd__or4_2
XFILLER_85_308 VGND VGND VPWR VPWR sky130_fd_sc_hd__decap_3
XFILLER_39_703 VGND VGND VPWR VPWR sky130_fd_sc_hd__decap_3
XFILLER_100_619 VGND VGND VPWR VPWR sky130_fd_sc_hd__decap_3
Xhold1009 _7201_/Q VGND VGND VPWR VPWR _5258_/A0 sky130_fd_sc_hd__dlygate4sd3_1
XFILLER_87_91 VGND VGND VPWR VPWR sky130_fd_sc_hd__fill_2
XFILLER_23_3 VGND VGND VPWR VPWR sky130_fd_sc_hd__fill_2
XFILLER_66_511 VGND VGND VPWR VPWR sky130_fd_sc_hd__decap_3
XFILLER_78_393 VGND VGND VPWR VPWR sky130_fd_sc_hd__decap_3
XFILLER_66_533 VGND VGND VPWR VPWR sky130_fd_sc_hd__decap_3
XFILLER_66_544 VGND VGND VPWR VPWR sky130_fd_sc_hd__decap_3
XFILLER_38_235 VGND VGND VPWR VPWR sky130_fd_sc_hd__decap_3
XFILLER_93_352 VGND VGND VPWR VPWR sky130_fd_sc_hd__decap_3
XFILLER_38_268 VGND VGND VPWR VPWR sky130_fd_sc_hd__decap_3
XFILLER_54_728 VGND VGND VPWR VPWR sky130_fd_sc_hd__decap_3
XFILLER_53_205 VGND VGND VPWR VPWR sky130_fd_sc_hd__decap_3
XFILLER_26_419 VGND VGND VPWR VPWR sky130_fd_sc_hd__fill_1
X_6961_ _6967_/CLK _6961_/D VGND VGND VPWR VPWR _6961_/Q sky130_fd_sc_hd__dfxtp_2
XTAP_TAPCELL_ROW_109_1681 VGND VPWR sky130_fd_sc_hd__tapvpwrvgnd_1
XFILLER_19_482 VGND VGND VPWR VPWR sky130_fd_sc_hd__decap_3
XFILLER_53_249 VGND VGND VPWR VPWR sky130_fd_sc_hd__decap_3
XFILLER_34_430 VGND VGND VPWR VPWR sky130_fd_sc_hd__decap_3
X_6892_ _7403_/CLK _6892_/D VGND VGND VPWR VPWR _6892_/Q sky130_fd_sc_hd__dfxtp_2
XFILLER_34_463 VGND VGND VPWR VPWR sky130_fd_sc_hd__decap_3
XFILLER_22_625 VGND VGND VPWR VPWR sky130_fd_sc_hd__decap_3
XFILLER_61_293 VGND VGND VPWR VPWR sky130_fd_sc_hd__decap_3
XFILLER_22_669 VGND VGND VPWR VPWR sky130_fd_sc_hd__decap_3
XTAP_TAPCELL_ROW_32_686 VGND VPWR sky130_fd_sc_hd__tapvpwrvgnd_1
X_4725_ _4969_/B _4720_/X _4723_/X _4724_/X VGND VGND VPWR VPWR _5655_/A sky130_fd_sc_hd__a211o_2
XFILLER_108_719 VGND VGND VPWR VPWR sky130_fd_sc_hd__decap_3
X_3607_ _4295_/B _3607_/B VGND VGND VPWR VPWR _3610_/A sky130_fd_sc_hd__nand2_2
Xhold810 _6870_/Q VGND VGND VPWR VPWR _6870_/D sky130_fd_sc_hd__dlygate4sd3_1
X_4587_ _4587_/A _4595_/B VGND VGND VPWR VPWR _7287_/D sky130_fd_sc_hd__and2_2
Xhold821 _6769_/Q VGND VGND VPWR VPWR _6769_/D sky130_fd_sc_hd__dlygate4sd3_1
X_7375_ _7387_/CLK _7375_/D _6655_/Y VGND VGND VPWR VPWR _7375_/Q sky130_fd_sc_hd__dfrtp_2
Xhold832 _6789_/Q VGND VGND VPWR VPWR _6789_/D sky130_fd_sc_hd__dlygate4sd3_1
Xhold843 _7116_/Q VGND VGND VPWR VPWR _7116_/D sky130_fd_sc_hd__dlygate4sd3_1
XTAP_TAPCELL_ROW_73_1213 VGND VPWR sky130_fd_sc_hd__tapvpwrvgnd_1
Xmax_cap562 _4537_/C VGND VGND VPWR VPWR _4289_/A sky130_fd_sc_hd__buf_2
XFILLER_89_603 VGND VGND VPWR VPWR sky130_fd_sc_hd__decap_3
X_3538_ _4327_/A _3456_/X _4537_/C _3421_/C VGND VGND VPWR VPWR _3544_/B sky130_fd_sc_hd__o2bb2a_2
X_6326_ _6680_/A VGND VGND VPWR VPWR _6326_/Y sky130_fd_sc_hd__inv_2
Xhold854 _7117_/Q VGND VGND VPWR VPWR _7117_/D sky130_fd_sc_hd__dlygate4sd3_1
XFILLER_107_13 VGND VGND VPWR VPWR sky130_fd_sc_hd__decap_3
Xhold865 _7114_/Q VGND VGND VPWR VPWR _7114_/D sky130_fd_sc_hd__dlygate4sd3_1
XFILLER_103_402 VGND VGND VPWR VPWR sky130_fd_sc_hd__decap_3
Xhold876 _7079_/Q VGND VGND VPWR VPWR _7079_/D sky130_fd_sc_hd__dlygate4sd3_1
XFILLER_1_529 VGND VGND VPWR VPWR sky130_fd_sc_hd__decap_3
Xhold887 _7097_/Q VGND VGND VPWR VPWR _7097_/D sky130_fd_sc_hd__dlygate4sd3_1
XFILLER_107_46 VGND VGND VPWR VPWR sky130_fd_sc_hd__decap_3
Xhold898 _7098_/Q VGND VGND VPWR VPWR _7098_/D sky130_fd_sc_hd__dlygate4sd3_1
XFILLER_89_647 VGND VGND VPWR VPWR sky130_fd_sc_hd__decap_3
X_3469_ _3469_/A _3469_/B VGND VGND VPWR VPWR _4537_/C sky130_fd_sc_hd__nor2_2
XFILLER_67_39 VGND VGND VPWR VPWR sky130_fd_sc_hd__decap_3
XFILLER_88_168 VGND VGND VPWR VPWR sky130_fd_sc_hd__fill_1
XTAP_TAPCELL_ROW_4_323 VGND VPWR sky130_fd_sc_hd__tapvpwrvgnd_1
XFILLER_69_360 VGND VGND VPWR VPWR sky130_fd_sc_hd__decap_3
XFILLER_97_691 VGND VGND VPWR VPWR sky130_fd_sc_hd__decap_3
XFILLER_57_522 VGND VGND VPWR VPWR sky130_fd_sc_hd__decap_3
XFILLER_69_393 VGND VGND VPWR VPWR sky130_fd_sc_hd__decap_3
X_5139_ _4677_/B _5138_/X _5092_/C VGND VGND VPWR VPWR _5139_/X sky130_fd_sc_hd__o21a_2
XFILLER_84_341 VGND VGND VPWR VPWR sky130_fd_sc_hd__decap_3
XFILLER_45_706 VGND VGND VPWR VPWR sky130_fd_sc_hd__decap_3
XFILLER_84_363 VGND VGND VPWR VPWR sky130_fd_sc_hd__fill_1
XFILLER_84_385 VGND VGND VPWR VPWR sky130_fd_sc_hd__decap_3
XFILLER_44_216 VGND VGND VPWR VPWR sky130_fd_sc_hd__decap_3
XFILLER_44_249 VGND VGND VPWR VPWR sky130_fd_sc_hd__decap_3
XFILLER_37_290 VGND VGND VPWR VPWR sky130_fd_sc_hd__decap_3
XFILLER_25_430 VGND VGND VPWR VPWR sky130_fd_sc_hd__decap_3
XTAP_TAPCELL_ROW_84_1353 VGND VPWR sky130_fd_sc_hd__tapvpwrvgnd_1
XFILLER_13_603 VGND VGND VPWR VPWR sky130_fd_sc_hd__decap_3
XTAP_TAPCELL_ROW_84_1364 VGND VPWR sky130_fd_sc_hd__tapvpwrvgnd_1
XFILLER_40_400 VGND VGND VPWR VPWR sky130_fd_sc_hd__decap_3
XFILLER_13_647 VGND VGND VPWR VPWR sky130_fd_sc_hd__decap_3
XFILLER_9_629 VGND VGND VPWR VPWR sky130_fd_sc_hd__decap_3
XFILLER_12_168 VGND VGND VPWR VPWR sky130_fd_sc_hd__decap_3
XFILLER_21_691 VGND VGND VPWR VPWR sky130_fd_sc_hd__decap_3
XFILLER_4_312 VGND VGND VPWR VPWR sky130_fd_sc_hd__decap_3
XFILLER_106_240 VGND VGND VPWR VPWR sky130_fd_sc_hd__decap_3
XFILLER_106_262 VGND VGND VPWR VPWR sky130_fd_sc_hd__decap_3
XFILLER_122_722 VGND VGND VPWR VPWR sky130_fd_sc_hd__decap_3
XFILLER_79_113 VGND VGND VPWR VPWR sky130_fd_sc_hd__decap_3
XFILLER_106_295 VGND VGND VPWR VPWR sky130_fd_sc_hd__decap_3
XFILLER_121_232 VGND VGND VPWR VPWR sky130_fd_sc_hd__decap_3
XFILLER_95_606 VGND VGND VPWR VPWR sky130_fd_sc_hd__decap_3
XFILLER_95_617 VGND VGND VPWR VPWR sky130_fd_sc_hd__decap_3
XFILLER_67_319 VGND VGND VPWR VPWR sky130_fd_sc_hd__decap_3
XFILLER_0_584 VGND VGND VPWR VPWR sky130_fd_sc_hd__decap_3
XFILLER_0_595 VGND VGND VPWR VPWR sky130_fd_sc_hd__fill_2
XFILLER_48_544 VGND VGND VPWR VPWR sky130_fd_sc_hd__decap_3
XFILLER_75_363 VGND VGND VPWR VPWR sky130_fd_sc_hd__decap_3
XFILLER_36_728 VGND VGND VPWR VPWR sky130_fd_sc_hd__decap_3
XFILLER_63_514 VGND VGND VPWR VPWR sky130_fd_sc_hd__decap_3
XFILLER_75_396 VGND VGND VPWR VPWR sky130_fd_sc_hd__decap_3
XFILLER_90_333 VGND VGND VPWR VPWR sky130_fd_sc_hd__decap_3
XFILLER_35_249 VGND VGND VPWR VPWR sky130_fd_sc_hd__decap_3
XFILLER_90_355 VGND VGND VPWR VPWR sky130_fd_sc_hd__decap_3
XFILLER_51_709 VGND VGND VPWR VPWR sky130_fd_sc_hd__decap_3
XFILLER_90_377 VGND VGND VPWR VPWR sky130_fd_sc_hd__decap_3
XFILLER_16_474 VGND VGND VPWR VPWR sky130_fd_sc_hd__fill_2
XFILLER_43_293 VGND VGND VPWR VPWR sky130_fd_sc_hd__decap_3
XFILLER_31_433 VGND VGND VPWR VPWR sky130_fd_sc_hd__decap_3
XFILLER_31_444 VGND VGND VPWR VPWR sky130_fd_sc_hd__decap_3
XFILLER_31_455 VGND VGND VPWR VPWR sky130_fd_sc_hd__decap_3
XFILLER_8_640 VGND VGND VPWR VPWR sky130_fd_sc_hd__decap_3
X_4510_ _4510_/A0 _7292_/Q _4520_/S VGND VGND VPWR VPWR _7324_/D sky130_fd_sc_hd__mux2_2
XFILLER_8_651 VGND VGND VPWR VPWR sky130_fd_sc_hd__decap_3
XFILLER_117_505 VGND VGND VPWR VPWR sky130_fd_sc_hd__decap_3
XFILLER_8_684 VGND VGND VPWR VPWR sky130_fd_sc_hd__decap_3
XFILLER_117_538 VGND VGND VPWR VPWR sky130_fd_sc_hd__decap_3
X_4441_ _4813_/B _4441_/B VGND VGND VPWR VPWR _4827_/A sky130_fd_sc_hd__nand2_2
XFILLER_7_172 VGND VGND VPWR VPWR sky130_fd_sc_hd__decap_3
XPHY_EDGE_ROW_9_Right_9 VGND VGND VPWR VPWR sky130_fd_sc_hd__decap_3
X_7160_ _7355_/CLK _7160_/D _6440_/Y VGND VGND VPWR VPWR _7160_/Q sky130_fd_sc_hd__dfrtp_2
XFILLER_113_700 VGND VGND VPWR VPWR sky130_fd_sc_hd__decap_3
X_4372_ _4372_/A _4627_/A VGND VGND VPWR VPWR _5018_/A sky130_fd_sc_hd__or2_2
XFILLER_98_411 VGND VGND VPWR VPWR sky130_fd_sc_hd__decap_3
X_3323_ _5129_/A _3519_/B _5294_/A _5129_/B VGND VGND VPWR VPWR _3323_/X sky130_fd_sc_hd__a31o_2
XFILLER_98_433 VGND VGND VPWR VPWR sky130_fd_sc_hd__decap_3
X_7091_ _7318_/CLK _7091_/D _6371_/Y VGND VGND VPWR VPWR _7091_/Q sky130_fd_sc_hd__dfrtp_2
XFILLER_98_466 VGND VGND VPWR VPWR sky130_fd_sc_hd__decap_3
XPHY_EDGE_ROW_107_Right_107 VGND VGND VPWR VPWR sky130_fd_sc_hd__decap_3
XFILLER_98_477 VGND VGND VPWR VPWR sky130_fd_sc_hd__decap_3
XFILLER_86_628 VGND VGND VPWR VPWR sky130_fd_sc_hd__decap_3
XFILLER_112_265 VGND VGND VPWR VPWR sky130_fd_sc_hd__decap_3
XFILLER_100_427 VGND VGND VPWR VPWR sky130_fd_sc_hd__decap_3
XFILLER_79_691 VGND VGND VPWR VPWR sky130_fd_sc_hd__decap_3
XFILLER_85_149 VGND VGND VPWR VPWR sky130_fd_sc_hd__decap_3
XFILLER_66_330 VGND VGND VPWR VPWR sky130_fd_sc_hd__fill_1
XFILLER_27_706 VGND VGND VPWR VPWR sky130_fd_sc_hd__decap_3
XFILLER_94_672 VGND VGND VPWR VPWR sky130_fd_sc_hd__decap_3
XFILLER_66_363 VGND VGND VPWR VPWR sky130_fd_sc_hd__fill_1
XFILLER_66_374 VGND VGND VPWR VPWR sky130_fd_sc_hd__decap_3
XFILLER_26_205 VGND VGND VPWR VPWR sky130_fd_sc_hd__decap_3
XFILLER_39_599 VGND VGND VPWR VPWR sky130_fd_sc_hd__decap_3
XFILLER_54_536 VGND VGND VPWR VPWR sky130_fd_sc_hd__fill_1
XFILLER_81_333 VGND VGND VPWR VPWR sky130_fd_sc_hd__decap_3
XFILLER_26_238 VGND VGND VPWR VPWR sky130_fd_sc_hd__decap_3
XTAP_TAPCELL_ROW_37_745 VGND VPWR sky130_fd_sc_hd__tapvpwrvgnd_1
XFILLER_26_249 VGND VGND VPWR VPWR sky130_fd_sc_hd__decap_3
X_6944_ _6965_/CLK _6944_/D VGND VGND VPWR VPWR _6944_/Q sky130_fd_sc_hd__dfxtp_2
XFILLER_81_388 VGND VGND VPWR VPWR sky130_fd_sc_hd__decap_3
XTAP_TAPCELL_ROW_120_1829 VGND VPWR sky130_fd_sc_hd__tapvpwrvgnd_1
X_6875_ _6926_/CLK _6875_/D VGND VGND VPWR VPWR _6875_/Q sky130_fd_sc_hd__dfxtp_2
XFILLER_34_271 VGND VGND VPWR VPWR sky130_fd_sc_hd__decap_3
XFILLER_22_411 VGND VGND VPWR VPWR sky130_fd_sc_hd__fill_2
XFILLER_50_731 VGND VGND VPWR VPWR sky130_fd_sc_hd__decap_3
XFILLER_22_433 VGND VGND VPWR VPWR sky130_fd_sc_hd__decap_3
XTAP_TAPCELL_ROW_17_491 VGND VPWR sky130_fd_sc_hd__tapvpwrvgnd_1
XFILLER_22_455 VGND VGND VPWR VPWR sky130_fd_sc_hd__decap_3
XFILLER_22_477 VGND VGND VPWR VPWR sky130_fd_sc_hd__decap_3
XFILLER_10_628 VGND VGND VPWR VPWR sky130_fd_sc_hd__decap_3
XFILLER_22_499 VGND VGND VPWR VPWR sky130_fd_sc_hd__decap_3
X_4708_ _7001_/Q _4825_/B VGND VGND VPWR VPWR _4826_/A sky130_fd_sc_hd__and2_2
X_5688_ _7350_/Q _5688_/A1 _5688_/S VGND VGND VPWR VPWR _6694_/D sky130_fd_sc_hd__mux2_2
XFILLER_118_12 VGND VGND VPWR VPWR sky130_fd_sc_hd__decap_3
X_4639_ _4639_/A _4948_/B VGND VGND VPWR VPWR _4918_/A sky130_fd_sc_hd__or2_2
XFILLER_118_56 VGND VGND VPWR VPWR sky130_fd_sc_hd__decap_3
XFILLER_123_519 VGND VGND VPWR VPWR sky130_fd_sc_hd__decap_3
Xhold640 _6783_/Q VGND VGND VPWR VPWR _6783_/D sky130_fd_sc_hd__dlygate4sd3_1
XFILLER_116_560 VGND VGND VPWR VPWR sky130_fd_sc_hd__decap_3
Xhold651 _6797_/Q VGND VGND VPWR VPWR _6797_/D sky130_fd_sc_hd__dlygate4sd3_1
X_7358_ _7360_/CLK _7358_/D _6638_/Y VGND VGND VPWR VPWR _7358_/Q sky130_fd_sc_hd__dfrtp_2
Xhold662 _6849_/Q VGND VGND VPWR VPWR _6849_/D sky130_fd_sc_hd__dlygate4sd3_1
XFILLER_104_722 VGND VGND VPWR VPWR sky130_fd_sc_hd__decap_3
Xhold673 _6854_/Q VGND VGND VPWR VPWR _6854_/D sky130_fd_sc_hd__dlygate4sd3_1
XFILLER_89_433 VGND VGND VPWR VPWR sky130_fd_sc_hd__decap_3
X_6309_ _6624_/A VGND VGND VPWR VPWR _6309_/Y sky130_fd_sc_hd__inv_2
Xhold684 _6745_/Q VGND VGND VPWR VPWR _6745_/D sky130_fd_sc_hd__dlygate4sd3_1
XFILLER_1_337 VGND VGND VPWR VPWR sky130_fd_sc_hd__decap_3
Xhold695 _6820_/Q VGND VGND VPWR VPWR _6820_/D sky130_fd_sc_hd__dlygate4sd3_1
XFILLER_89_455 VGND VGND VPWR VPWR sky130_fd_sc_hd__decap_3
X_7289_ _7356_/CLK _7289_/D _6569_/Y VGND VGND VPWR VPWR _7289_/Q sky130_fd_sc_hd__dfrtp_2
XFILLER_77_606 VGND VGND VPWR VPWR sky130_fd_sc_hd__decap_3
XFILLER_77_617 VGND VGND VPWR VPWR sky130_fd_sc_hd__decap_3
XFILLER_49_308 VGND VGND VPWR VPWR sky130_fd_sc_hd__decap_3
XFILLER_89_488 VGND VGND VPWR VPWR sky130_fd_sc_hd__decap_3
XFILLER_76_138 VGND VGND VPWR VPWR sky130_fd_sc_hd__fill_2
XFILLER_94_26 VGND VGND VPWR VPWR sky130_fd_sc_hd__fill_2
XFILLER_76_149 VGND VGND VPWR VPWR sky130_fd_sc_hd__decap_3
XFILLER_69_190 VGND VGND VPWR VPWR sky130_fd_sc_hd__decap_3
XFILLER_85_650 VGND VGND VPWR VPWR sky130_fd_sc_hd__decap_3
XFILLER_45_503 VGND VGND VPWR VPWR sky130_fd_sc_hd__fill_1
XFILLER_18_728 VGND VGND VPWR VPWR sky130_fd_sc_hd__decap_3
XFILLER_85_694 VGND VGND VPWR VPWR sky130_fd_sc_hd__decap_3
XFILLER_17_249 VGND VGND VPWR VPWR sky130_fd_sc_hd__decap_3
XFILLER_33_709 VGND VGND VPWR VPWR sky130_fd_sc_hd__decap_3
XFILLER_72_377 VGND VGND VPWR VPWR sky130_fd_sc_hd__decap_3
XFILLER_60_517 VGND VGND VPWR VPWR sky130_fd_sc_hd__fill_1
XFILLER_32_219 VGND VGND VPWR VPWR sky130_fd_sc_hd__decap_3
XFILLER_60_539 VGND VGND VPWR VPWR sky130_fd_sc_hd__decap_3
XFILLER_72_399 VGND VGND VPWR VPWR sky130_fd_sc_hd__decap_3
XFILLER_13_422 VGND VGND VPWR VPWR sky130_fd_sc_hd__decap_3
XFILLER_25_293 VGND VGND VPWR VPWR sky130_fd_sc_hd__fill_1
XFILLER_40_241 VGND VGND VPWR VPWR sky130_fd_sc_hd__decap_3
XFILLER_9_437 VGND VGND VPWR VPWR sky130_fd_sc_hd__decap_3
XTAP_TAPCELL_ROW_97_1522 VGND VPWR sky130_fd_sc_hd__tapvpwrvgnd_1
XTAP_TAPCELL_ROW_97_1533 VGND VPWR sky130_fd_sc_hd__tapvpwrvgnd_1
XFILLER_5_632 VGND VGND VPWR VPWR sky130_fd_sc_hd__decap_3
XFILLER_57_9 VGND VGND VPWR VPWR sky130_fd_sc_hd__fill_2
XFILLER_114_508 VGND VGND VPWR VPWR sky130_fd_sc_hd__decap_3
XFILLER_5_665 VGND VGND VPWR VPWR sky130_fd_sc_hd__decap_3
XFILLER_5_676 VGND VGND VPWR VPWR sky130_fd_sc_hd__decap_3
XFILLER_107_582 VGND VGND VPWR VPWR sky130_fd_sc_hd__decap_3
XFILLER_4_35 VGND VGND VPWR VPWR sky130_fd_sc_hd__fill_2
XFILLER_4_197 VGND VGND VPWR VPWR sky130_fd_sc_hd__decap_3
XFILLER_122_563 VGND VGND VPWR VPWR sky130_fd_sc_hd__decap_3
XFILLER_95_414 VGND VGND VPWR VPWR sky130_fd_sc_hd__decap_3
XFILLER_68_628 VGND VGND VPWR VPWR sky130_fd_sc_hd__decap_3
XFILLER_110_725 VGND VGND VPWR VPWR sky130_fd_sc_hd__decap_3
XFILLER_67_116 VGND VGND VPWR VPWR sky130_fd_sc_hd__fill_2
XFILLER_95_447 VGND VGND VPWR VPWR sky130_fd_sc_hd__fill_1
XFILLER_95_458 VGND VGND VPWR VPWR sky130_fd_sc_hd__fill_2
XFILLER_83_609 VGND VGND VPWR VPWR sky130_fd_sc_hd__decap_3
XFILLER_48_330 VGND VGND VPWR VPWR sky130_fd_sc_hd__decap_3
XFILLER_82_119 VGND VGND VPWR VPWR sky130_fd_sc_hd__decap_3
XFILLER_76_672 VGND VGND VPWR VPWR sky130_fd_sc_hd__decap_3
XFILLER_48_363 VGND VGND VPWR VPWR sky130_fd_sc_hd__fill_1
XFILLER_91_620 VGND VGND VPWR VPWR sky130_fd_sc_hd__decap_3
Xplace300 _3913_/A2 VGND VGND VPWR VPWR _3898_/B1 sky130_fd_sc_hd__buf_2
XFILLER_75_193 VGND VGND VPWR VPWR sky130_fd_sc_hd__decap_3
Xplace311 _3605_/Y VGND VGND VPWR VPWR _5146_/B1 sky130_fd_sc_hd__buf_2
XFILLER_91_653 VGND VGND VPWR VPWR sky130_fd_sc_hd__decap_3
Xplace322 _4327_/A VGND VGND VPWR VPWR _4425_/A sky130_fd_sc_hd__buf_2
XFILLER_90_141 VGND VGND VPWR VPWR sky130_fd_sc_hd__decap_3
XFILLER_63_355 VGND VGND VPWR VPWR sky130_fd_sc_hd__decap_3
XTAP_TAPCELL_ROW_106_1640 VGND VPWR sky130_fd_sc_hd__tapvpwrvgnd_1
X_4990_ _4620_/A _4989_/X _4374_/X VGND VGND VPWR VPWR _5004_/B sky130_fd_sc_hd__o21ai_2
XTAP_TAPCELL_ROW_106_1651 VGND VPWR sky130_fd_sc_hd__tapvpwrvgnd_1
XTAP_TAPCELL_ROW_34_704 VGND VPWR sky130_fd_sc_hd__tapvpwrvgnd_1
Xplace333 _5737_/S VGND VGND VPWR VPWR _5735_/S sky130_fd_sc_hd__buf_2
XTAP_TAPCELL_ROW_34_715 VGND VPWR sky130_fd_sc_hd__tapvpwrvgnd_1
Xplace344 _5398_/S VGND VGND VPWR VPWR _5383_/S sky130_fd_sc_hd__buf_2
Xplace355 _3417_/X VGND VGND VPWR VPWR _4335_/B1 sky130_fd_sc_hd__buf_2
XFILLER_91_697 VGND VGND VPWR VPWR sky130_fd_sc_hd__decap_3
XFILLER_63_388 VGND VGND VPWR VPWR sky130_fd_sc_hd__decap_3
X_3941_ _7369_/Q _4484_/A0 _3945_/S VGND VGND VPWR VPWR _7369_/D sky130_fd_sc_hd__mux2_2
Xplace366 _4265_/B VGND VGND VPWR VPWR _4102_/B sky130_fd_sc_hd__buf_2
Xplace377 _3991_/A VGND VGND VPWR VPWR _5151_/A sky130_fd_sc_hd__buf_2
XFILLER_32_731 VGND VGND VPWR VPWR sky130_fd_sc_hd__decap_3
Xplace388 _5225_/B VGND VGND VPWR VPWR _5207_/B sky130_fd_sc_hd__buf_2
XFILLER_16_293 VGND VGND VPWR VPWR sky130_fd_sc_hd__decap_3
Xplace399 _4520_/S VGND VGND VPWR VPWR _4505_/S sky130_fd_sc_hd__buf_2
XFILLER_90_3 VGND VGND VPWR VPWR sky130_fd_sc_hd__decap_3
X_3872_ _6921_/Q _3926_/A2 _3925_/A2 _6695_/Q _3871_/X VGND VGND VPWR VPWR _3872_/X
+ sky130_fd_sc_hd__a221o_2
X_6660_ _6660_/A VGND VGND VPWR VPWR _6660_/Y sky130_fd_sc_hd__inv_2
XFILLER_31_252 VGND VGND VPWR VPWR sky130_fd_sc_hd__fill_1
XTAP_TAPCELL_ROW_14_450 VGND VPWR sky130_fd_sc_hd__tapvpwrvgnd_1
X_5611_ _5611_/A _5634_/B VGND VGND VPWR VPWR _7022_/D sky130_fd_sc_hd__and2_2
X_6591_ _6591_/A VGND VGND VPWR VPWR _6591_/Y sky130_fd_sc_hd__inv_2
XFILLER_31_296 VGND VGND VPWR VPWR sky130_fd_sc_hd__fill_2
XFILLER_8_470 VGND VGND VPWR VPWR sky130_fd_sc_hd__decap_3
XTAP_TAPCELL_ROW_57_1005 VGND VPWR sky130_fd_sc_hd__tapvpwrvgnd_1
XFILLER_117_357 VGND VGND VPWR VPWR sky130_fd_sc_hd__decap_3
XFILLER_105_508 VGND VGND VPWR VPWR sky130_fd_sc_hd__fill_1
X_4424_ _4425_/A _4425_/C _4649_/B VGND VGND VPWR VPWR _4446_/A sky130_fd_sc_hd__a21oi_2
X_7212_ _7372_/CLK _7212_/D _6492_/Y VGND VGND VPWR VPWR _7212_/Q sky130_fd_sc_hd__dfrtp_2
XTAP_TAPCELL_ROW_117_1791 VGND VPWR sky130_fd_sc_hd__tapvpwrvgnd_1
X_4355_ _4355_/A _4355_/B VGND VGND VPWR VPWR _4355_/X sky130_fd_sc_hd__or2_2
X_7143_ _7399_/CLK _7143_/D _6423_/Y VGND VGND VPWR VPWR _7143_/Q sky130_fd_sc_hd__dfrtp_2
XFILLER_113_541 VGND VGND VPWR VPWR sky130_fd_sc_hd__decap_3
XFILLER_59_606 VGND VGND VPWR VPWR sky130_fd_sc_hd__decap_3
XFILLER_59_617 VGND VGND VPWR VPWR sky130_fd_sc_hd__decap_3
XFILLER_101_703 VGND VGND VPWR VPWR sky130_fd_sc_hd__decap_3
X_3306_ _3340_/A _3328_/A _6981_/D _4696_/B _3340_/B VGND VGND VPWR VPWR _3378_/A
+ sky130_fd_sc_hd__o221a_2
X_7074_ _7398_/CLK _7074_/D _6354_/Y VGND VGND VPWR VPWR _7074_/Q sky130_fd_sc_hd__dfrtp_2
X_4286_ _4286_/A _4286_/B VGND VGND VPWR VPWR _4288_/C sky130_fd_sc_hd__or2_2
XFILLER_113_585 VGND VGND VPWR VPWR sky130_fd_sc_hd__decap_3
XFILLER_86_436 VGND VGND VPWR VPWR sky130_fd_sc_hd__decap_3
XFILLER_58_138 VGND VGND VPWR VPWR sky130_fd_sc_hd__fill_2
XFILLER_100_224 VGND VGND VPWR VPWR sky130_fd_sc_hd__decap_3
XFILLER_86_469 VGND VGND VPWR VPWR sky130_fd_sc_hd__decap_3
XFILLER_67_650 VGND VGND VPWR VPWR sky130_fd_sc_hd__decap_3
XFILLER_104_14 VGND VGND VPWR VPWR sky130_fd_sc_hd__decap_3
XFILLER_100_268 VGND VGND VPWR VPWR sky130_fd_sc_hd__decap_3
XFILLER_39_363 VGND VGND VPWR VPWR sky130_fd_sc_hd__decap_3
XFILLER_27_514 VGND VGND VPWR VPWR sky130_fd_sc_hd__decap_3
XFILLER_67_694 VGND VGND VPWR VPWR sky130_fd_sc_hd__decap_3
XFILLER_82_631 VGND VGND VPWR VPWR sky130_fd_sc_hd__decap_3
XFILLER_39_396 VGND VGND VPWR VPWR sky130_fd_sc_hd__decap_3
XFILLER_54_333 VGND VGND VPWR VPWR sky130_fd_sc_hd__decap_3
XTAP_TAPCELL_ROW_68_1145 VGND VPWR sky130_fd_sc_hd__tapvpwrvgnd_1
XFILLER_27_558 VGND VGND VPWR VPWR sky130_fd_sc_hd__fill_2
XTAP_TAPCELL_ROW_68_1156 VGND VPWR sky130_fd_sc_hd__tapvpwrvgnd_1
XFILLER_81_130 VGND VGND VPWR VPWR sky130_fd_sc_hd__fill_1
XFILLER_15_709 VGND VGND VPWR VPWR sky130_fd_sc_hd__decap_3
XFILLER_82_675 VGND VGND VPWR VPWR sky130_fd_sc_hd__decap_3
XFILLER_81_163 VGND VGND VPWR VPWR sky130_fd_sc_hd__decap_3
XFILLER_42_528 VGND VGND VPWR VPWR sky130_fd_sc_hd__decap_3
X_6927_ _6965_/CLK _6927_/D VGND VGND VPWR VPWR _6927_/Q sky130_fd_sc_hd__dfxtp_2
XFILLER_54_399 VGND VGND VPWR VPWR sky130_fd_sc_hd__decap_3
XFILLER_120_35 VGND VGND VPWR VPWR sky130_fd_sc_hd__decap_3
XTAP_TAPCELL_ROW_81_1323 VGND VPWR sky130_fd_sc_hd__tapvpwrvgnd_1
XFILLER_35_591 VGND VGND VPWR VPWR sky130_fd_sc_hd__decap_3
Xfanout23 _6598_/A VGND VGND VPWR VPWR _6596_/A sky130_fd_sc_hd__buf_2
Xfanout34 _6637_/A VGND VGND VPWR VPWR _6624_/A sky130_fd_sc_hd__clkbuf_2
XFILLER_120_68 VGND VGND VPWR VPWR sky130_fd_sc_hd__decap_3
X_6858_ clkload4/A _6858_/D VGND VGND VPWR VPWR _6858_/Q sky130_fd_sc_hd__dfxtp_2
Xfanout45 fanout46/X VGND VGND VPWR VPWR _6612_/A sky130_fd_sc_hd__clkdlybuf4s25_1
XFILLER_22_241 VGND VGND VPWR VPWR sky130_fd_sc_hd__decap_3
Xfanout56 _6653_/A VGND VGND VPWR VPWR _6650_/A sky130_fd_sc_hd__buf_2
Xfanout67 _6553_/A VGND VGND VPWR VPWR _6649_/A sky130_fd_sc_hd__buf_2
XFILLER_22_274 VGND VGND VPWR VPWR sky130_fd_sc_hd__decap_3
X_6789_ _7380_/CLK _6789_/D VGND VGND VPWR VPWR _6789_/Q sky130_fd_sc_hd__dfxtp_2
XTAP_TAPCELL_ROW_79_1296 VGND VPWR sky130_fd_sc_hd__tapvpwrvgnd_1
XFILLER_123_305 VGND VGND VPWR VPWR sky130_fd_sc_hd__decap_3
XFILLER_108_379 VGND VGND VPWR VPWR sky130_fd_sc_hd__decap_3
XFILLER_2_635 VGND VGND VPWR VPWR sky130_fd_sc_hd__decap_3
XTAP_TAPCELL_ROW_92_1463 VGND VPWR sky130_fd_sc_hd__tapvpwrvgnd_1
XFILLER_2_657 VGND VGND VPWR VPWR sky130_fd_sc_hd__decap_3
XFILLER_89_252 VGND VGND VPWR VPWR sky130_fd_sc_hd__decap_3
XFILLER_104_563 VGND VGND VPWR VPWR sky130_fd_sc_hd__decap_3
XFILLER_89_296 VGND VGND VPWR VPWR sky130_fd_sc_hd__decap_3
XFILLER_49_149 VGND VGND VPWR VPWR sky130_fd_sc_hd__fill_2
XFILLER_58_672 VGND VGND VPWR VPWR sky130_fd_sc_hd__decap_3
Xhold1170 _7182_/Q VGND VGND VPWR VPWR _5296_/A0 sky130_fd_sc_hd__dlygate4sd3_1
XFILLER_85_480 VGND VGND VPWR VPWR sky130_fd_sc_hd__decap_3
XFILLER_73_620 VGND VGND VPWR VPWR sky130_fd_sc_hd__decap_3
XFILLER_45_311 VGND VGND VPWR VPWR sky130_fd_sc_hd__decap_3
XFILLER_38_96 VGND VGND VPWR VPWR sky130_fd_sc_hd__decap_3
XFILLER_57_182 VGND VGND VPWR VPWR sky130_fd_sc_hd__decap_3
XFILLER_18_536 VGND VGND VPWR VPWR sky130_fd_sc_hd__fill_1
Xhold1181 _7153_/Q VGND VGND VPWR VPWR _5356_/A0 sky130_fd_sc_hd__dlygate4sd3_1
XFILLER_45_333 VGND VGND VPWR VPWR sky130_fd_sc_hd__decap_3
Xhold1192 _7164_/Q VGND VGND VPWR VPWR _5333_/A0 sky130_fd_sc_hd__dlygate4sd3_1
XFILLER_73_653 VGND VGND VPWR VPWR sky130_fd_sc_hd__decap_3
XFILLER_72_130 VGND VGND VPWR VPWR sky130_fd_sc_hd__decap_3
XFILLER_18_569 VGND VGND VPWR VPWR sky130_fd_sc_hd__decap_3
XFILLER_72_141 VGND VGND VPWR VPWR sky130_fd_sc_hd__decap_3
XFILLER_45_355 VGND VGND VPWR VPWR sky130_fd_sc_hd__decap_3
XFILLER_73_697 VGND VGND VPWR VPWR sky130_fd_sc_hd__decap_3
XFILLER_72_174 VGND VGND VPWR VPWR sky130_fd_sc_hd__decap_3
XFILLER_60_314 VGND VGND VPWR VPWR sky130_fd_sc_hd__decap_3
XFILLER_45_399 VGND VGND VPWR VPWR sky130_fd_sc_hd__decap_3
XFILLER_26_580 VGND VGND VPWR VPWR sky130_fd_sc_hd__decap_3
XFILLER_14_731 VGND VGND VPWR VPWR sky130_fd_sc_hd__decap_3
XFILLER_60_347 VGND VGND VPWR VPWR sky130_fd_sc_hd__decap_3
XFILLER_41_550 VGND VGND VPWR VPWR sky130_fd_sc_hd__fill_1
XFILLER_13_252 VGND VGND VPWR VPWR sky130_fd_sc_hd__decap_3
XFILLER_9_245 VGND VGND VPWR VPWR sky130_fd_sc_hd__decap_3
XFILLER_13_296 VGND VGND VPWR VPWR sky130_fd_sc_hd__decap_3
XTAP_TAPCELL_ROW_101_1581 VGND VPWR sky130_fd_sc_hd__tapvpwrvgnd_1
XFILLER_9_278 VGND VGND VPWR VPWR sky130_fd_sc_hd__fill_2
Xclkload15 _7279_/CLK VGND VGND VPWR VPWR clkload15/X sky130_fd_sc_hd__clkbuf_8
Xclkload26 _7372_/CLK VGND VGND VPWR VPWR clkload26/Y sky130_fd_sc_hd__clkinv_2
XFILLER_55_6 VGND VGND VPWR VPWR sky130_fd_sc_hd__decap_3
XFILLER_79_81 VGND VGND VPWR VPWR sky130_fd_sc_hd__decap_3
XFILLER_96_701 VGND VGND VPWR VPWR sky130_fd_sc_hd__decap_3
X_4140_ _4117_/Y _4124_/B _4890_/B _4886_/A VGND VGND VPWR VPWR _4140_/X sky130_fd_sc_hd__a2bb2o_2
XFILLER_96_734 VGND VGND VPWR VPWR sky130_fd_sc_hd__fill_1
XFILLER_95_211 VGND VGND VPWR VPWR sky130_fd_sc_hd__fill_1
XFILLER_95_222 VGND VGND VPWR VPWR sky130_fd_sc_hd__fill_2
XFILLER_68_436 VGND VGND VPWR VPWR sky130_fd_sc_hd__decap_3
XFILLER_110_533 VGND VGND VPWR VPWR sky130_fd_sc_hd__decap_3
X_4071_ _7307_/Q _4488_/S _4437_/B1 _7371_/Q _4429_/C1 VGND VGND VPWR VPWR _4071_/X
+ sky130_fd_sc_hd__a221o_2
XFILLER_68_469 VGND VGND VPWR VPWR sky130_fd_sc_hd__decap_3
XFILLER_49_650 VGND VGND VPWR VPWR sky130_fd_sc_hd__decap_3
XFILLER_110_566 VGND VGND VPWR VPWR sky130_fd_sc_hd__decap_3
XFILLER_95_266 VGND VGND VPWR VPWR sky130_fd_sc_hd__decap_3
XFILLER_55_108 VGND VGND VPWR VPWR sky130_fd_sc_hd__decap_3
XFILLER_49_694 VGND VGND VPWR VPWR sky130_fd_sc_hd__decap_3
XFILLER_64_631 VGND VGND VPWR VPWR sky130_fd_sc_hd__decap_3
XTAP_TAPCELL_ROW_19_520 VGND VPWR sky130_fd_sc_hd__tapvpwrvgnd_1
XFILLER_36_333 VGND VGND VPWR VPWR sky130_fd_sc_hd__decap_3
XFILLER_64_675 VGND VGND VPWR VPWR sky130_fd_sc_hd__decap_3
XTAP_TAPCELL_ROW_47_873 VGND VPWR sky130_fd_sc_hd__tapvpwrvgnd_1
XFILLER_91_461 VGND VGND VPWR VPWR sky130_fd_sc_hd__decap_3
XFILLER_36_377 VGND VGND VPWR VPWR sky130_fd_sc_hd__decap_3
XTAP_TAPCELL_ROW_47_884 VGND VPWR sky130_fd_sc_hd__tapvpwrvgnd_1
XFILLER_24_528 VGND VGND VPWR VPWR sky130_fd_sc_hd__decap_3
XFILLER_51_314 VGND VGND VPWR VPWR sky130_fd_sc_hd__decap_3
X_4973_ _5581_/S _4973_/B _3813_/Y VGND VGND VPWR VPWR _4973_/X sky130_fd_sc_hd__or3b_2
XFILLER_63_196 VGND VGND VPWR VPWR sky130_fd_sc_hd__decap_3
XFILLER_17_591 VGND VGND VPWR VPWR sky130_fd_sc_hd__decap_3
X_6712_ _7371_/CLK _6712_/D VGND VGND VPWR VPWR _6712_/Q sky130_fd_sc_hd__dfxtp_2
XFILLER_51_358 VGND VGND VPWR VPWR sky130_fd_sc_hd__decap_3
X_3924_ _3924_/A1 _5151_/A _3923_/X VGND VGND VPWR VPWR _7376_/D sky130_fd_sc_hd__o21a_2
XFILLER_20_701 VGND VGND VPWR VPWR sky130_fd_sc_hd__decap_3
XFILLER_32_583 VGND VGND VPWR VPWR sky130_fd_sc_hd__decap_3
XTAP_TAPCELL_ROW_63_1086 VGND VPWR sky130_fd_sc_hd__tapvpwrvgnd_1
X_6643_ _6643_/A VGND VGND VPWR VPWR _6643_/Y sky130_fd_sc_hd__inv_2
XFILLER_20_734 VGND VGND VPWR VPWR sky130_fd_sc_hd__fill_1
X_3855_ _3728_/Y _3847_/X _3849_/X _3714_/X _3854_/X VGND VGND VPWR VPWR _3855_/X
+ sky130_fd_sc_hd__a221o_2
Xclkload9 clkload9/A VGND VGND VPWR VPWR clkload9/X sky130_fd_sc_hd__clkbuf_1
XTAP_TAPCELL_ROW_119_1820 VGND VPWR sky130_fd_sc_hd__tapvpwrvgnd_1
X_3786_ _6751_/Q _3661_/X _3656_/Y _6733_/Q VGND VGND VPWR VPWR _3786_/X sky130_fd_sc_hd__a22o_2
X_6574_ _6608_/A VGND VGND VPWR VPWR _6574_/Y sky130_fd_sc_hd__inv_2
XFILLER_118_622 VGND VGND VPWR VPWR sky130_fd_sc_hd__decap_3
XFILLER_118_666 VGND VGND VPWR VPWR sky130_fd_sc_hd__decap_3
XFILLER_117_154 VGND VGND VPWR VPWR sky130_fd_sc_hd__fill_1
XFILLER_118_699 VGND VGND VPWR VPWR sky130_fd_sc_hd__fill_1
Xoutput520 _7009_/Q VGND VGND VPWR VPWR pc_out[0] sky130_fd_sc_hd__clkdlybuf4s25_1
Xoutput531 _7010_/Q VGND VGND VPWR VPWR pc_out[1] sky130_fd_sc_hd__clkdlybuf4s25_1
XFILLER_59_29 VGND VGND VPWR VPWR sky130_fd_sc_hd__decap_3
Xoutput542 _5667_/A VGND VGND VPWR VPWR pc_out[2] sky130_fd_sc_hd__clkdlybuf4s25_1
X_4407_ _7370_/Q _4394_/B _4436_/B1 _7178_/Q _4406_/X VGND VGND VPWR VPWR _4407_/X
+ sky130_fd_sc_hd__a221o_2
XFILLER_99_550 VGND VGND VPWR VPWR sky130_fd_sc_hd__decap_3
XFILLER_99_561 VGND VGND VPWR VPWR sky130_fd_sc_hd__decap_3
XFILLER_87_712 VGND VGND VPWR VPWR sky130_fd_sc_hd__decap_3
X_7126_ _7318_/CLK _7126_/D _6406_/Y VGND VGND VPWR VPWR _7126_/Q sky130_fd_sc_hd__dfrtp_2
XFILLER_59_414 VGND VGND VPWR VPWR sky130_fd_sc_hd__decap_3
XFILLER_115_13 VGND VGND VPWR VPWR sky130_fd_sc_hd__decap_3
X_4338_ _7319_/Q _3989_/S _4346_/B1 _7351_/Q _4248_/A VGND VGND VPWR VPWR _4338_/X
+ sky130_fd_sc_hd__a221o_2
XFILLER_99_594 VGND VGND VPWR VPWR sky130_fd_sc_hd__decap_3
XFILLER_113_371 VGND VGND VPWR VPWR sky130_fd_sc_hd__decap_3
XFILLER_101_511 VGND VGND VPWR VPWR sky130_fd_sc_hd__decap_3
XFILLER_115_46 VGND VGND VPWR VPWR sky130_fd_sc_hd__decap_3
XFILLER_113_393 VGND VGND VPWR VPWR sky130_fd_sc_hd__decap_3
XFILLER_86_233 VGND VGND VPWR VPWR sky130_fd_sc_hd__decap_3
XFILLER_115_57 VGND VGND VPWR VPWR sky130_fd_sc_hd__decap_3
X_4269_ _7230_/Q _4353_/A2 _4244_/B _7043_/Q _4268_/X VGND VGND VPWR VPWR _4271_/C
+ sky130_fd_sc_hd__a221o_2
X_7057_ _7279_/CLK _7057_/D _6337_/Y VGND VGND VPWR VPWR _7057_/Q sky130_fd_sc_hd__dfrtp_2
XFILLER_101_555 VGND VGND VPWR VPWR sky130_fd_sc_hd__decap_3
XFILLER_46_108 VGND VGND VPWR VPWR sky130_fd_sc_hd__decap_3
XFILLER_86_277 VGND VGND VPWR VPWR sky130_fd_sc_hd__decap_3
XFILLER_101_588 VGND VGND VPWR VPWR sky130_fd_sc_hd__decap_3
XFILLER_86_299 VGND VGND VPWR VPWR sky130_fd_sc_hd__decap_3
XFILLER_55_620 VGND VGND VPWR VPWR sky130_fd_sc_hd__decap_3
XFILLER_27_311 VGND VGND VPWR VPWR sky130_fd_sc_hd__decap_3
XFILLER_67_491 VGND VGND VPWR VPWR sky130_fd_sc_hd__decap_3
XFILLER_55_653 VGND VGND VPWR VPWR sky130_fd_sc_hd__decap_3
XFILLER_27_355 VGND VGND VPWR VPWR sky130_fd_sc_hd__fill_1
XFILLER_70_601 VGND VGND VPWR VPWR sky130_fd_sc_hd__decap_3
XFILLER_82_472 VGND VGND VPWR VPWR sky130_fd_sc_hd__decap_3
XFILLER_54_163 VGND VGND VPWR VPWR sky130_fd_sc_hd__decap_3
XFILLER_15_517 VGND VGND VPWR VPWR sky130_fd_sc_hd__decap_3
XFILLER_82_483 VGND VGND VPWR VPWR sky130_fd_sc_hd__decap_3
XFILLER_55_697 VGND VGND VPWR VPWR sky130_fd_sc_hd__decap_3
XFILLER_70_634 VGND VGND VPWR VPWR sky130_fd_sc_hd__decap_3
XFILLER_27_399 VGND VGND VPWR VPWR sky130_fd_sc_hd__decap_3
XFILLER_70_645 VGND VGND VPWR VPWR sky130_fd_sc_hd__decap_3
XFILLER_42_336 VGND VGND VPWR VPWR sky130_fd_sc_hd__decap_3
XFILLER_70_678 VGND VGND VPWR VPWR sky130_fd_sc_hd__decap_3
XFILLER_23_561 VGND VGND VPWR VPWR sky130_fd_sc_hd__fill_1
XFILLER_11_712 VGND VGND VPWR VPWR sky130_fd_sc_hd__decap_3
XTAP_TAPCELL_ROW_25_589 VGND VPWR sky130_fd_sc_hd__tapvpwrvgnd_1
XFILLER_23_583 VGND VGND VPWR VPWR sky130_fd_sc_hd__decap_3
XFILLER_10_200 VGND VGND VPWR VPWR sky130_fd_sc_hd__fill_1
XFILLER_109_600 VGND VGND VPWR VPWR sky130_fd_sc_hd__decap_3
XFILLER_7_727 VGND VGND VPWR VPWR sky130_fd_sc_hd__fill_1
XFILLER_6_215 VGND VGND VPWR VPWR sky130_fd_sc_hd__decap_3
XFILLER_6_226 VGND VGND VPWR VPWR sky130_fd_sc_hd__fill_2
XFILLER_10_277 VGND VGND VPWR VPWR sky130_fd_sc_hd__decap_3
XFILLER_108_110 VGND VGND VPWR VPWR sky130_fd_sc_hd__decap_3
XFILLER_109_644 VGND VGND VPWR VPWR sky130_fd_sc_hd__decap_3
XFILLER_109_688 VGND VGND VPWR VPWR sky130_fd_sc_hd__decap_3
XFILLER_108_165 VGND VGND VPWR VPWR sky130_fd_sc_hd__fill_1
XFILLER_123_113 VGND VGND VPWR VPWR sky130_fd_sc_hd__decap_3
XFILLER_108_187 VGND VGND VPWR VPWR sky130_fd_sc_hd__decap_3
XFILLER_2_421 VGND VGND VPWR VPWR sky130_fd_sc_hd__decap_3
XFILLER_78_701 VGND VGND VPWR VPWR sky130_fd_sc_hd__decap_3
XFILLER_111_308 VGND VGND VPWR VPWR sky130_fd_sc_hd__decap_3
XFILLER_104_360 VGND VGND VPWR VPWR sky130_fd_sc_hd__decap_3
XFILLER_78_734 VGND VGND VPWR VPWR sky130_fd_sc_hd__fill_1
XFILLER_104_371 VGND VGND VPWR VPWR sky130_fd_sc_hd__decap_3
XFILLER_77_211 VGND VGND VPWR VPWR sky130_fd_sc_hd__decap_3
XFILLER_2_498 VGND VGND VPWR VPWR sky130_fd_sc_hd__decap_3
XFILLER_93_715 VGND VGND VPWR VPWR sky130_fd_sc_hd__decap_3
XFILLER_77_277 VGND VGND VPWR VPWR sky130_fd_sc_hd__decap_3
XFILLER_92_214 VGND VGND VPWR VPWR sky130_fd_sc_hd__fill_2
XFILLER_65_428 VGND VGND VPWR VPWR sky130_fd_sc_hd__decap_3
XFILLER_77_299 VGND VGND VPWR VPWR sky130_fd_sc_hd__decap_3
XFILLER_46_620 VGND VGND VPWR VPWR sky130_fd_sc_hd__decap_3
XFILLER_92_247 VGND VGND VPWR VPWR sky130_fd_sc_hd__decap_3
XFILLER_18_355 VGND VGND VPWR VPWR sky130_fd_sc_hd__decap_3
XFILLER_46_675 VGND VGND VPWR VPWR sky130_fd_sc_hd__decap_3
XFILLER_61_623 VGND VGND VPWR VPWR sky130_fd_sc_hd__decap_3
XFILLER_18_388 VGND VGND VPWR VPWR sky130_fd_sc_hd__decap_3
XTAP_TAPCELL_ROW_103_1610 VGND VPWR sky130_fd_sc_hd__tapvpwrvgnd_1
XFILLER_33_325 VGND VGND VPWR VPWR sky130_fd_sc_hd__decap_3
XFILLER_45_196 VGND VGND VPWR VPWR sky130_fd_sc_hd__decap_3
XTAP_TAPCELL_ROW_44_843 VGND VPWR sky130_fd_sc_hd__tapvpwrvgnd_1
XFILLER_61_656 VGND VGND VPWR VPWR sky130_fd_sc_hd__decap_3
XFILLER_33_358 VGND VGND VPWR VPWR sky130_fd_sc_hd__fill_1
XFILLER_33_369 VGND VGND VPWR VPWR sky130_fd_sc_hd__fill_2
XFILLER_14_561 VGND VGND VPWR VPWR sky130_fd_sc_hd__decap_3
XFILLER_60_177 VGND VGND VPWR VPWR sky130_fd_sc_hd__decap_3
XFILLER_81_71 VGND VGND VPWR VPWR sky130_fd_sc_hd__fill_2
XFILLER_119_408 VGND VGND VPWR VPWR sky130_fd_sc_hd__decap_3
X_3640_ _3635_/X _3637_/X _3639_/X VGND VGND VPWR VPWR _3640_/X sky130_fd_sc_hd__o21ba_2
X_3571_ _3326_/A _3424_/S _5648_/B _3569_/X _3570_/X VGND VGND VPWR VPWR _3607_/B
+ sky130_fd_sc_hd__o32a_2
XFILLER_115_603 VGND VGND VPWR VPWR sky130_fd_sc_hd__decap_3
X_5310_ _5310_/A0 _4836_/X _5315_/S VGND VGND VPWR VPWR _7175_/D sky130_fd_sc_hd__mux2_2
X_6290_ _6366_/A VGND VGND VPWR VPWR _6290_/Y sky130_fd_sc_hd__inv_2
XFILLER_53_3 VGND VGND VPWR VPWR sky130_fd_sc_hd__fill_1
XFILLER_5_270 VGND VGND VPWR VPWR sky130_fd_sc_hd__decap_3
XFILLER_115_647 VGND VGND VPWR VPWR sky130_fd_sc_hd__decap_3
XFILLER_5_281 VGND VGND VPWR VPWR sky130_fd_sc_hd__decap_3
XTAP_TAPCELL_ROW_114_1750 VGND VPWR sky130_fd_sc_hd__tapvpwrvgnd_1
X_5241_ _5241_/A0 _4806_/X _5258_/S VGND VGND VPWR VPWR _7209_/D sky130_fd_sc_hd__mux2_2
XFILLER_69_712 VGND VGND VPWR VPWR sky130_fd_sc_hd__decap_3
XFILLER_114_179 VGND VGND VPWR VPWR sky130_fd_sc_hd__decap_3
XFILLER_102_319 VGND VGND VPWR VPWR sky130_fd_sc_hd__decap_3
XFILLER_68_200 VGND VGND VPWR VPWR sky130_fd_sc_hd__decap_3
XFILLER_96_542 VGND VGND VPWR VPWR sky130_fd_sc_hd__decap_3
X_4123_ _4119_/X _4122_/X _4327_/A VGND VGND VPWR VPWR _4124_/B sky130_fd_sc_hd__o21a_2
XFILLER_84_704 VGND VGND VPWR VPWR sky130_fd_sc_hd__decap_3
XFILLER_96_575 VGND VGND VPWR VPWR sky130_fd_sc_hd__decap_3
XFILLER_68_277 VGND VGND VPWR VPWR sky130_fd_sc_hd__decap_3
XFILLER_56_417 VGND VGND VPWR VPWR sky130_fd_sc_hd__decap_3
X_4054_ _4054_/A _4456_/A VGND VGND VPWR VPWR _4658_/A sky130_fd_sc_hd__nand2_2
XFILLER_56_439 VGND VGND VPWR VPWR sky130_fd_sc_hd__fill_1
XFILLER_83_225 VGND VGND VPWR VPWR sky130_fd_sc_hd__decap_3
XFILLER_37_620 VGND VGND VPWR VPWR sky130_fd_sc_hd__decap_3
XFILLER_49_491 VGND VGND VPWR VPWR sky130_fd_sc_hd__decap_3
XFILLER_83_258 VGND VGND VPWR VPWR sky130_fd_sc_hd__decap_3
XFILLER_37_653 VGND VGND VPWR VPWR sky130_fd_sc_hd__decap_3
XFILLER_64_450 VGND VGND VPWR VPWR sky130_fd_sc_hd__decap_3
XTAP_TAPCELL_ROW_65_1115 VGND VPWR sky130_fd_sc_hd__tapvpwrvgnd_1
XFILLER_64_483 VGND VGND VPWR VPWR sky130_fd_sc_hd__decap_3
XFILLER_37_697 VGND VGND VPWR VPWR sky130_fd_sc_hd__decap_3
XFILLER_52_634 VGND VGND VPWR VPWR sky130_fd_sc_hd__decap_3
XFILLER_24_325 VGND VGND VPWR VPWR sky130_fd_sc_hd__decap_3
XFILLER_52_645 VGND VGND VPWR VPWR sky130_fd_sc_hd__decap_3
XFILLER_52_678 VGND VGND VPWR VPWR sky130_fd_sc_hd__decap_3
X_4956_ _4948_/Y _4951_/Y _4954_/X _4955_/X VGND VGND VPWR VPWR _5662_/C sky130_fd_sc_hd__a211o_2
X_3907_ _6781_/Q _3926_/B1 _3665_/X _6869_/Q _3906_/X VGND VGND VPWR VPWR _3907_/X
+ sky130_fd_sc_hd__a221o_2
XFILLER_51_199 VGND VGND VPWR VPWR sky130_fd_sc_hd__decap_3
XTAP_TAPCELL_ROW_22_548 VGND VPWR sky130_fd_sc_hd__tapvpwrvgnd_1
X_4887_ _4886_/A _4890_/B _4814_/A VGND VGND VPWR VPWR _4887_/Y sky130_fd_sc_hd__a21oi_2
XTAP_TAPCELL_ROW_22_559 VGND VPWR sky130_fd_sc_hd__tapvpwrvgnd_1
X_6626_ _6626_/A VGND VGND VPWR VPWR _6626_/Y sky130_fd_sc_hd__inv_2
X_3838_ _6773_/Q _3851_/A2 _3840_/A2 _6761_/Q _3837_/X VGND VGND VPWR VPWR _3838_/X
+ sky130_fd_sc_hd__a221o_2
XFILLER_20_575 VGND VGND VPWR VPWR sky130_fd_sc_hd__decap_3
XFILLER_118_430 VGND VGND VPWR VPWR sky130_fd_sc_hd__decap_3
X_6557_ _6557_/A VGND VGND VPWR VPWR _6557_/Y sky130_fd_sc_hd__inv_2
X_3769_ _3746_/C _3767_/X _3768_/X _4799_/A VGND VGND VPWR VPWR _4944_/B sky130_fd_sc_hd__o31a_2
XFILLER_4_719 VGND VGND VPWR VPWR sky130_fd_sc_hd__decap_3
XFILLER_3_218 VGND VGND VPWR VPWR sky130_fd_sc_hd__decap_3
XFILLER_106_625 VGND VGND VPWR VPWR sky130_fd_sc_hd__decap_3
XFILLER_105_102 VGND VGND VPWR VPWR sky130_fd_sc_hd__fill_2
XTAP_TAPCELL_ROW_76_1255 VGND VPWR sky130_fd_sc_hd__tapvpwrvgnd_1
X_6488_ _6654_/A VGND VGND VPWR VPWR _6488_/Y sky130_fd_sc_hd__inv_2
XFILLER_106_669 VGND VGND VPWR VPWR sky130_fd_sc_hd__decap_3
XFILLER_121_606 VGND VGND VPWR VPWR sky130_fd_sc_hd__decap_3
XFILLER_10_78 VGND VGND VPWR VPWR sky130_fd_sc_hd__decap_3
XFILLER_121_617 VGND VGND VPWR VPWR sky130_fd_sc_hd__decap_3
XFILLER_99_380 VGND VGND VPWR VPWR sky130_fd_sc_hd__decap_3
XFILLER_99_391 VGND VGND VPWR VPWR sky130_fd_sc_hd__fill_1
X_7109_ _7368_/CLK _7109_/D _6389_/Y VGND VGND VPWR VPWR _7109_/Q sky130_fd_sc_hd__dfrtp_2
XFILLER_87_564 VGND VGND VPWR VPWR sky130_fd_sc_hd__decap_3
XFILLER_75_715 VGND VGND VPWR VPWR sky130_fd_sc_hd__decap_3
XFILLER_74_203 VGND VGND VPWR VPWR sky130_fd_sc_hd__decap_3
XFILLER_59_277 VGND VGND VPWR VPWR sky130_fd_sc_hd__decap_3
XFILLER_87_597 VGND VGND VPWR VPWR sky130_fd_sc_hd__decap_3
XFILLER_19_119 VGND VGND VPWR VPWR sky130_fd_sc_hd__decap_3
XFILLER_101_374 VGND VGND VPWR VPWR sky130_fd_sc_hd__fill_1
XFILLER_74_236 VGND VGND VPWR VPWR sky130_fd_sc_hd__decap_3
XFILLER_28_631 VGND VGND VPWR VPWR sky130_fd_sc_hd__decap_3
XFILLER_90_707 VGND VGND VPWR VPWR sky130_fd_sc_hd__decap_3
XFILLER_28_675 VGND VGND VPWR VPWR sky130_fd_sc_hd__decap_3
XFILLER_35_20 VGND VGND VPWR VPWR sky130_fd_sc_hd__decap_3
XTAP_TAPCELL_ROW_2_295 VGND VPWR sky130_fd_sc_hd__tapvpwrvgnd_1
XFILLER_55_483 VGND VGND VPWR VPWR sky130_fd_sc_hd__decap_3
XFILLER_43_623 VGND VGND VPWR VPWR sky130_fd_sc_hd__decap_3
XTAP_TAPCELL_ROW_87_1395 VGND VPWR sky130_fd_sc_hd__tapvpwrvgnd_1
XFILLER_82_280 VGND VGND VPWR VPWR sky130_fd_sc_hd__fill_1
XFILLER_70_442 VGND VGND VPWR VPWR sky130_fd_sc_hd__decap_3
XFILLER_43_656 VGND VGND VPWR VPWR sky130_fd_sc_hd__decap_3
XTAP_TAPCELL_ROW_41_802 VGND VPWR sky130_fd_sc_hd__tapvpwrvgnd_1
XFILLER_70_486 VGND VGND VPWR VPWR sky130_fd_sc_hd__decap_3
XFILLER_42_188 VGND VGND VPWR VPWR sky130_fd_sc_hd__decap_3
XFILLER_11_553 VGND VGND VPWR VPWR sky130_fd_sc_hd__decap_3
XFILLER_11_564 VGND VGND VPWR VPWR sky130_fd_sc_hd__decap_3
XFILLER_11_597 VGND VGND VPWR VPWR sky130_fd_sc_hd__decap_3
XFILLER_7_557 VGND VGND VPWR VPWR sky130_fd_sc_hd__decap_3
XFILLER_7_579 VGND VGND VPWR VPWR sky130_fd_sc_hd__decap_3
XFILLER_109_485 VGND VGND VPWR VPWR sky130_fd_sc_hd__decap_3
XFILLER_97_317 VGND VGND VPWR VPWR sky130_fd_sc_hd__decap_3
XFILLER_112_628 VGND VGND VPWR VPWR sky130_fd_sc_hd__decap_3
XFILLER_111_116 VGND VGND VPWR VPWR sky130_fd_sc_hd__decap_3
XFILLER_105_691 VGND VGND VPWR VPWR sky130_fd_sc_hd__decap_3
XFILLER_78_531 VGND VGND VPWR VPWR sky130_fd_sc_hd__fill_1
XFILLER_78_542 VGND VGND VPWR VPWR sky130_fd_sc_hd__decap_3
XFILLER_111_149 VGND VGND VPWR VPWR sky130_fd_sc_hd__decap_3
XFILLER_104_190 VGND VGND VPWR VPWR sky130_fd_sc_hd__decap_3
XFILLER_66_704 VGND VGND VPWR VPWR sky130_fd_sc_hd__decap_3
XTAP_TAPCELL_ROW_49_902 VGND VPWR sky130_fd_sc_hd__tapvpwrvgnd_1
XFILLER_93_501 VGND VGND VPWR VPWR sky130_fd_sc_hd__decap_3
XFILLER_120_672 VGND VGND VPWR VPWR sky130_fd_sc_hd__decap_3
XFILLER_76_71 VGND VGND VPWR VPWR sky130_fd_sc_hd__fill_2
XFILLER_19_620 VGND VGND VPWR VPWR sky130_fd_sc_hd__decap_3
XFILLER_93_556 VGND VGND VPWR VPWR sky130_fd_sc_hd__decap_3
XFILLER_93_567 VGND VGND VPWR VPWR sky130_fd_sc_hd__decap_3
XFILLER_65_258 VGND VGND VPWR VPWR sky130_fd_sc_hd__fill_2
XFILLER_19_653 VGND VGND VPWR VPWR sky130_fd_sc_hd__decap_3
XFILLER_81_718 VGND VGND VPWR VPWR sky130_fd_sc_hd__decap_3
XFILLER_81_729 VGND VGND VPWR VPWR sky130_fd_sc_hd__decap_3
XFILLER_80_206 VGND VGND VPWR VPWR sky130_fd_sc_hd__decap_3
XFILLER_34_601 VGND VGND VPWR VPWR sky130_fd_sc_hd__decap_3
XFILLER_18_152 VGND VGND VPWR VPWR sky130_fd_sc_hd__fill_2
XFILLER_80_228 VGND VGND VPWR VPWR sky130_fd_sc_hd__decap_3
XFILLER_19_697 VGND VGND VPWR VPWR sky130_fd_sc_hd__decap_3
XFILLER_34_634 VGND VGND VPWR VPWR sky130_fd_sc_hd__decap_3
XFILLER_34_645 VGND VGND VPWR VPWR sky130_fd_sc_hd__decap_3
XFILLER_33_122 VGND VGND VPWR VPWR sky130_fd_sc_hd__decap_3
XFILLER_61_442 VGND VGND VPWR VPWR sky130_fd_sc_hd__decap_3
X_4810_ _4813_/A _4810_/B _4829_/B VGND VGND VPWR VPWR _4810_/X sky130_fd_sc_hd__or3_2
XFILLER_34_678 VGND VGND VPWR VPWR sky130_fd_sc_hd__decap_3
XFILLER_33_155 VGND VGND VPWR VPWR sky130_fd_sc_hd__decap_3
XFILLER_33_188 VGND VGND VPWR VPWR sky130_fd_sc_hd__decap_3
X_4741_ _4761_/B _4761_/C _4762_/B VGND VGND VPWR VPWR _4741_/X sky130_fd_sc_hd__a21o_2
XFILLER_14_380 VGND VGND VPWR VPWR sky130_fd_sc_hd__fill_2
XTAP_TAPCELL_ROW_60_1045 VGND VPWR sky130_fd_sc_hd__tapvpwrvgnd_1
X_4672_ _6991_/Q _4690_/B VGND VGND VPWR VPWR _4673_/B sky130_fd_sc_hd__nor2_2
X_6411_ _6602_/A VGND VGND VPWR VPWR _6411_/Y sky130_fd_sc_hd__inv_2
X_7391_ _7401_/CLK _7391_/D _6671_/Y VGND VGND VPWR VPWR _7391_/Q sky130_fd_sc_hd__dfrtp_2
XFILLER_115_400 VGND VGND VPWR VPWR sky130_fd_sc_hd__decap_3
X_6342_ _6630_/A VGND VGND VPWR VPWR _6342_/Y sky130_fd_sc_hd__inv_2
X_3554_ _7317_/Q _3977_/S _4278_/B1 _7349_/Q VGND VGND VPWR VPWR _3556_/B sky130_fd_sc_hd__a22o_2
XFILLER_115_433 VGND VGND VPWR VPWR sky130_fd_sc_hd__decap_3
XFILLER_115_455 VGND VGND VPWR VPWR sky130_fd_sc_hd__decap_3
X_3485_ _3502_/A _3502_/B _3485_/C VGND VGND VPWR VPWR _5144_/A sky130_fd_sc_hd__or3_4
X_6273_ _6275_/A VGND VGND VPWR VPWR _6273_/Y sky130_fd_sc_hd__inv_2
XFILLER_103_606 VGND VGND VPWR VPWR sky130_fd_sc_hd__decap_3
XFILLER_103_617 VGND VGND VPWR VPWR sky130_fd_sc_hd__decap_3
XFILLER_69_553 VGND VGND VPWR VPWR sky130_fd_sc_hd__decap_3
X_5155_ _4467_/B _3923_/X _5151_/X _5154_/Y VGND VGND VPWR VPWR _5155_/X sky130_fd_sc_hd__a31o_2
XFILLER_96_350 VGND VGND VPWR VPWR sky130_fd_sc_hd__decap_3
XFILLER_111_650 VGND VGND VPWR VPWR sky130_fd_sc_hd__decap_3
XTAP_TAPCELL_ROW_71_1185 VGND VPWR sky130_fd_sc_hd__tapvpwrvgnd_1
XFILLER_57_715 VGND VGND VPWR VPWR sky130_fd_sc_hd__decap_3
XFILLER_56_203 VGND VGND VPWR VPWR sky130_fd_sc_hd__decap_3
XTAP_TAPCELL_ROW_71_1196 VGND VPWR sky130_fd_sc_hd__tapvpwrvgnd_1
X_4106_ _7141_/Q _4267_/A2 _4103_/X _4105_/X VGND VGND VPWR VPWR _4106_/X sky130_fd_sc_hd__a211o_2
XFILLER_111_694 VGND VGND VPWR VPWR sky130_fd_sc_hd__decap_3
X_5086_ _5086_/A _5101_/B _5100_/B VGND VGND VPWR VPWR _5086_/X sky130_fd_sc_hd__and3_2
XFILLER_110_193 VGND VGND VPWR VPWR sky130_fd_sc_hd__decap_3
XFILLER_72_707 VGND VGND VPWR VPWR sky130_fd_sc_hd__decap_3
X_4037_ _4394_/A _4394_/B _4036_/X VGND VGND VPWR VPWR _4458_/A sky130_fd_sc_hd__or3b_2
XFILLER_84_578 VGND VGND VPWR VPWR sky130_fd_sc_hd__decap_3
XFILLER_112_14 VGND VGND VPWR VPWR sky130_fd_sc_hd__decap_3
XFILLER_84_589 VGND VGND VPWR VPWR sky130_fd_sc_hd__decap_3
XTAP_TAPCELL_ROW_27_618 VGND VPWR sky130_fd_sc_hd__tapvpwrvgnd_1
XFILLER_25_612 VGND VGND VPWR VPWR sky130_fd_sc_hd__decap_3
XFILLER_25_623 VGND VGND VPWR VPWR sky130_fd_sc_hd__decap_3
XFILLER_112_47 VGND VGND VPWR VPWR sky130_fd_sc_hd__decap_3
XFILLER_64_280 VGND VGND VPWR VPWR sky130_fd_sc_hd__decap_3
XFILLER_72_29 VGND VGND VPWR VPWR sky130_fd_sc_hd__decap_3
XFILLER_25_656 VGND VGND VPWR VPWR sky130_fd_sc_hd__decap_3
XFILLER_24_133 VGND VGND VPWR VPWR sky130_fd_sc_hd__decap_3
XFILLER_24_144 VGND VGND VPWR VPWR sky130_fd_sc_hd__decap_3
XFILLER_52_464 VGND VGND VPWR VPWR sky130_fd_sc_hd__decap_3
XFILLER_40_604 VGND VGND VPWR VPWR sky130_fd_sc_hd__decap_3
XFILLER_24_177 VGND VGND VPWR VPWR sky130_fd_sc_hd__decap_3
XFILLER_40_637 VGND VGND VPWR VPWR sky130_fd_sc_hd__decap_3
XFILLER_12_328 VGND VGND VPWR VPWR sky130_fd_sc_hd__fill_2
XFILLER_40_648 VGND VGND VPWR VPWR sky130_fd_sc_hd__decap_3
X_4939_ _4764_/B _4379_/B _4938_/Y _4937_/A _4852_/A VGND VGND VPWR VPWR _4939_/X
+ sky130_fd_sc_hd__o32a_2
XFILLER_21_11 VGND VGND VPWR VPWR sky130_fd_sc_hd__fill_2
X_6609_ _6610_/A VGND VGND VPWR VPWR _6609_/Y sky130_fd_sc_hd__inv_2
XFILLER_21_33 VGND VGND VPWR VPWR sky130_fd_sc_hd__decap_3
XFILLER_4_516 VGND VGND VPWR VPWR sky130_fd_sc_hd__decap_3
XFILLER_118_282 VGND VGND VPWR VPWR sky130_fd_sc_hd__decap_3
XTAP_TAPCELL_ROW_7_354 VGND VPWR sky130_fd_sc_hd__tapvpwrvgnd_1
XFILLER_121_458 VGND VGND VPWR VPWR sky130_fd_sc_hd__decap_3
XFILLER_94_309 VGND VGND VPWR VPWR sky130_fd_sc_hd__decap_3
XFILLER_48_704 VGND VGND VPWR VPWR sky130_fd_sc_hd__decap_3
XFILLER_102_672 VGND VGND VPWR VPWR sky130_fd_sc_hd__decap_3
XTAP_TAPCELL_ROW_89_1424 VGND VPWR sky130_fd_sc_hd__tapvpwrvgnd_1
XFILLER_75_523 VGND VGND VPWR VPWR sky130_fd_sc_hd__fill_2
XFILLER_47_214 VGND VGND VPWR VPWR sky130_fd_sc_hd__decap_3
XFILLER_101_160 VGND VGND VPWR VPWR sky130_fd_sc_hd__decap_3
XFILLER_47_225 VGND VGND VPWR VPWR sky130_fd_sc_hd__fill_1
XFILLER_75_545 VGND VGND VPWR VPWR sky130_fd_sc_hd__decap_3
XFILLER_47_247 VGND VGND VPWR VPWR sky130_fd_sc_hd__decap_3
XFILLER_63_718 VGND VGND VPWR VPWR sky130_fd_sc_hd__decap_3
XFILLER_63_729 VGND VGND VPWR VPWR sky130_fd_sc_hd__decap_3
XFILLER_62_206 VGND VGND VPWR VPWR sky130_fd_sc_hd__decap_3
XFILLER_16_601 VGND VGND VPWR VPWR sky130_fd_sc_hd__decap_3
XFILLER_62_217 VGND VGND VPWR VPWR sky130_fd_sc_hd__decap_3
XFILLER_46_74 VGND VGND VPWR VPWR sky130_fd_sc_hd__fill_1
XFILLER_28_483 VGND VGND VPWR VPWR sky130_fd_sc_hd__decap_3
XFILLER_46_85 VGND VGND VPWR VPWR sky130_fd_sc_hd__decap_3
XFILLER_16_634 VGND VGND VPWR VPWR sky130_fd_sc_hd__decap_3
XFILLER_43_420 VGND VGND VPWR VPWR sky130_fd_sc_hd__decap_3
XFILLER_16_645 VGND VGND VPWR VPWR sky130_fd_sc_hd__decap_3
XFILLER_55_291 VGND VGND VPWR VPWR sky130_fd_sc_hd__decap_3
XFILLER_43_464 VGND VGND VPWR VPWR sky130_fd_sc_hd__decap_3
XFILLER_16_678 VGND VGND VPWR VPWR sky130_fd_sc_hd__decap_3
XTAP_TAPCELL_ROW_54_971 VGND VPWR sky130_fd_sc_hd__tapvpwrvgnd_1
XFILLER_70_250 VGND VGND VPWR VPWR sky130_fd_sc_hd__fill_2
XFILLER_31_615 VGND VGND VPWR VPWR sky130_fd_sc_hd__fill_1
XFILLER_15_166 VGND VGND VPWR VPWR sky130_fd_sc_hd__fill_2
XFILLER_102_80 VGND VGND VPWR VPWR sky130_fd_sc_hd__decap_3
XFILLER_70_272 VGND VGND VPWR VPWR sky130_fd_sc_hd__decap_3
XFILLER_43_486 VGND VGND VPWR VPWR sky130_fd_sc_hd__fill_1
XFILLER_31_626 VGND VGND VPWR VPWR sky130_fd_sc_hd__decap_3
XFILLER_30_103 VGND VGND VPWR VPWR sky130_fd_sc_hd__decap_3
XFILLER_31_659 VGND VGND VPWR VPWR sky130_fd_sc_hd__decap_3
XFILLER_87_9 VGND VGND VPWR VPWR sky130_fd_sc_hd__decap_3
XFILLER_7_332 VGND VGND VPWR VPWR sky130_fd_sc_hd__decap_3
XFILLER_117_709 VGND VGND VPWR VPWR sky130_fd_sc_hd__decap_3
XFILLER_109_260 VGND VGND VPWR VPWR sky130_fd_sc_hd__decap_3
XFILLER_98_604 VGND VGND VPWR VPWR sky130_fd_sc_hd__decap_3
XFILLER_112_414 VGND VGND VPWR VPWR sky130_fd_sc_hd__decap_3
XFILLER_98_637 VGND VGND VPWR VPWR sky130_fd_sc_hd__decap_3
XFILLER_98_648 VGND VGND VPWR VPWR sky130_fd_sc_hd__decap_3
XFILLER_3_582 VGND VGND VPWR VPWR sky130_fd_sc_hd__decap_3
XFILLER_112_436 VGND VGND VPWR VPWR sky130_fd_sc_hd__decap_3
XFILLER_97_147 VGND VGND VPWR VPWR sky130_fd_sc_hd__decap_3
XFILLER_87_70 VGND VGND VPWR VPWR sky130_fd_sc_hd__fill_2
XFILLER_97_169 VGND VGND VPWR VPWR sky130_fd_sc_hd__decap_3
XFILLER_39_715 VGND VGND VPWR VPWR sky130_fd_sc_hd__decap_3
XFILLER_78_361 VGND VGND VPWR VPWR sky130_fd_sc_hd__decap_3
XFILLER_38_203 VGND VGND VPWR VPWR sky130_fd_sc_hd__decap_3
XFILLER_78_383 VGND VGND VPWR VPWR sky130_fd_sc_hd__decap_3
XFILLER_120_480 VGND VGND VPWR VPWR sky130_fd_sc_hd__decap_3
XFILLER_66_556 VGND VGND VPWR VPWR sky130_fd_sc_hd__decap_3
XFILLER_54_707 VGND VGND VPWR VPWR sky130_fd_sc_hd__decap_3
XFILLER_26_409 VGND VGND VPWR VPWR sky130_fd_sc_hd__decap_3
X_6960_ _6960_/CLK _6960_/D VGND VGND VPWR VPWR _6960_/Q sky130_fd_sc_hd__dfxtp_2
XFILLER_93_364 VGND VGND VPWR VPWR sky130_fd_sc_hd__decap_3
XFILLER_53_217 VGND VGND VPWR VPWR sky130_fd_sc_hd__decap_3
XFILLER_19_472 VGND VGND VPWR VPWR sky130_fd_sc_hd__decap_3
XFILLER_53_228 VGND VGND VPWR VPWR sky130_fd_sc_hd__decap_3
XTAP_TAPCELL_ROW_109_1682 VGND VPWR sky130_fd_sc_hd__tapvpwrvgnd_1
XFILLER_46_280 VGND VGND VPWR VPWR sky130_fd_sc_hd__decap_3
XFILLER_19_494 VGND VGND VPWR VPWR sky130_fd_sc_hd__decap_3
X_6891_ _7403_/CLK _6891_/D VGND VGND VPWR VPWR _6891_/Q sky130_fd_sc_hd__dfxtp_2
XFILLER_81_559 VGND VGND VPWR VPWR sky130_fd_sc_hd__fill_1
XFILLER_34_442 VGND VGND VPWR VPWR sky130_fd_sc_hd__decap_3
XFILLER_22_604 VGND VGND VPWR VPWR sky130_fd_sc_hd__decap_3
XFILLER_34_475 VGND VGND VPWR VPWR sky130_fd_sc_hd__fill_1
XFILLER_61_272 VGND VGND VPWR VPWR sky130_fd_sc_hd__decap_3
XFILLER_22_637 VGND VGND VPWR VPWR sky130_fd_sc_hd__decap_3
XFILLER_22_648 VGND VGND VPWR VPWR sky130_fd_sc_hd__decap_3
XFILLER_21_147 VGND VGND VPWR VPWR sky130_fd_sc_hd__fill_1
X_4724_ _4720_/A _4655_/X _4658_/B VGND VGND VPWR VPWR _4724_/X sky130_fd_sc_hd__o21a_2
XFILLER_21_169 VGND VGND VPWR VPWR sky130_fd_sc_hd__decap_3
XTAP_TAPCELL_ROW_32_687 VGND VPWR sky130_fd_sc_hd__tapvpwrvgnd_1
XFILLER_30_681 VGND VGND VPWR VPWR sky130_fd_sc_hd__decap_3
X_4655_ _4745_/A _4765_/B _4611_/Y _4762_/A _4744_/B VGND VGND VPWR VPWR _4655_/X
+ sky130_fd_sc_hd__a221o_2
XFILLER_107_208 VGND VGND VPWR VPWR sky130_fd_sc_hd__decap_3
X_3606_ _4614_/B _3603_/B _5146_/B1 VGND VGND VPWR VPWR _3606_/X sky130_fd_sc_hd__o21a_2
Xhold800 _6964_/Q VGND VGND VPWR VPWR _6964_/D sky130_fd_sc_hd__dlygate4sd3_1
Xhold811 _6928_/Q VGND VGND VPWR VPWR _6928_/D sky130_fd_sc_hd__dlygate4sd3_1
X_7374_ _7374_/CLK _7374_/D _6654_/Y VGND VGND VPWR VPWR _7374_/Q sky130_fd_sc_hd__dfrtp_2
XFILLER_116_731 VGND VGND VPWR VPWR sky130_fd_sc_hd__decap_3
Xhold822 _6889_/Q VGND VGND VPWR VPWR _6889_/D sky130_fd_sc_hd__dlygate4sd3_1
Xhold833 _6720_/Q VGND VGND VPWR VPWR _6720_/D sky130_fd_sc_hd__dlygate4sd3_1
X_6325_ _6642_/A VGND VGND VPWR VPWR _6325_/Y sky130_fd_sc_hd__inv_2
Xmax_cap552 _4069_/Y VGND VGND VPWR VPWR _4745_/A sky130_fd_sc_hd__clkbuf_2
Xhold844 _7094_/Q VGND VGND VPWR VPWR _7094_/D sky130_fd_sc_hd__dlygate4sd3_1
XTAP_TAPCELL_ROW_73_1214 VGND VPWR sky130_fd_sc_hd__tapvpwrvgnd_1
X_3537_ _3427_/B _3521_/Y _5057_/A _3527_/A _3536_/Y VGND VGND VPWR VPWR _3537_/X
+ sky130_fd_sc_hd__o221a_2
Xmax_cap563 _6557_/A VGND VGND VPWR VPWR _6556_/A sky130_fd_sc_hd__buf_2
Xhold855 _7066_/Q VGND VGND VPWR VPWR _7066_/D sky130_fd_sc_hd__dlygate4sd3_1
XFILLER_1_508 VGND VGND VPWR VPWR sky130_fd_sc_hd__decap_3
Xmax_cap574 _6685_/A VGND VGND VPWR VPWR _6686_/A sky130_fd_sc_hd__buf_2
Xhold866 _7115_/Q VGND VGND VPWR VPWR _7115_/D sky130_fd_sc_hd__dlygate4sd3_1
XFILLER_89_615 VGND VGND VPWR VPWR sky130_fd_sc_hd__fill_1
XFILLER_107_25 VGND VGND VPWR VPWR sky130_fd_sc_hd__decap_3
XFILLER_89_626 VGND VGND VPWR VPWR sky130_fd_sc_hd__decap_3
Xhold877 _7090_/Q VGND VGND VPWR VPWR _7090_/D sky130_fd_sc_hd__dlygate4sd3_1
Xhold888 _7099_/Q VGND VGND VPWR VPWR _7099_/D sky130_fd_sc_hd__dlygate4sd3_1
Xhold899 _7102_/Q VGND VGND VPWR VPWR _7102_/D sky130_fd_sc_hd__dlygate4sd3_1
XFILLER_89_659 VGND VGND VPWR VPWR sky130_fd_sc_hd__decap_3
XFILLER_103_436 VGND VGND VPWR VPWR sky130_fd_sc_hd__decap_3
X_3468_ _7281_/Q _5157_/S _4335_/B1 _7089_/Q _3467_/X VGND VGND VPWR VPWR _3468_/X
+ sky130_fd_sc_hd__a221o_2
XFILLER_88_136 VGND VGND VPWR VPWR sky130_fd_sc_hd__decap_3
XFILLER_67_18 VGND VGND VPWR VPWR sky130_fd_sc_hd__decap_3
XFILLER_103_458 VGND VGND VPWR VPWR sky130_fd_sc_hd__decap_3
X_5207_ _5207_/A _5207_/B VGND VGND VPWR VPWR _7225_/D sky130_fd_sc_hd__and2_2
XFILLER_76_309 VGND VGND VPWR VPWR sky130_fd_sc_hd__decap_3
XTAP_TAPCELL_ROW_4_313 VGND VPWR sky130_fd_sc_hd__tapvpwrvgnd_1
XTAP_TAPCELL_ROW_4_324 VGND VPWR sky130_fd_sc_hd__tapvpwrvgnd_1
X_3399_ _3977_/S _3399_/B VGND VGND VPWR VPWR _3449_/B sky130_fd_sc_hd__nor2_4
XFILLER_69_372 VGND VGND VPWR VPWR sky130_fd_sc_hd__fill_1
XFILLER_29_214 VGND VGND VPWR VPWR sky130_fd_sc_hd__decap_3
X_5138_ _3665_/B _3914_/X _5151_/A VGND VGND VPWR VPWR _5138_/X sky130_fd_sc_hd__mux2_2
XFILLER_29_225 VGND VGND VPWR VPWR sky130_fd_sc_hd__decap_3
XFILLER_123_35 VGND VGND VPWR VPWR sky130_fd_sc_hd__decap_3
XFILLER_29_247 VGND VGND VPWR VPWR sky130_fd_sc_hd__decap_3
XFILLER_45_718 VGND VGND VPWR VPWR sky130_fd_sc_hd__decap_3
XFILLER_123_57 VGND VGND VPWR VPWR sky130_fd_sc_hd__decap_3
X_5069_ _6987_/Q _5069_/B VGND VGND VPWR VPWR _5069_/X sky130_fd_sc_hd__or2_2
XFILLER_45_729 VGND VGND VPWR VPWR sky130_fd_sc_hd__decap_3
XFILLER_83_39 VGND VGND VPWR VPWR sky130_fd_sc_hd__decap_3
XFILLER_44_228 VGND VGND VPWR VPWR sky130_fd_sc_hd__decap_3
XFILLER_84_397 VGND VGND VPWR VPWR sky130_fd_sc_hd__decap_3
XFILLER_72_548 VGND VGND VPWR VPWR sky130_fd_sc_hd__decap_3
XFILLER_25_442 VGND VGND VPWR VPWR sky130_fd_sc_hd__decap_3
XTAP_TAPCELL_ROW_84_1354 VGND VPWR sky130_fd_sc_hd__tapvpwrvgnd_1
XTAP_TAPCELL_ROW_84_1365 VGND VPWR sky130_fd_sc_hd__tapvpwrvgnd_1
XFILLER_13_615 VGND VGND VPWR VPWR sky130_fd_sc_hd__fill_1
XFILLER_13_626 VGND VGND VPWR VPWR sky130_fd_sc_hd__decap_3
XFILLER_52_272 VGND VGND VPWR VPWR sky130_fd_sc_hd__decap_3
XFILLER_40_412 VGND VGND VPWR VPWR sky130_fd_sc_hd__decap_3
XFILLER_80_592 VGND VGND VPWR VPWR sky130_fd_sc_hd__decap_3
XFILLER_52_283 VGND VGND VPWR VPWR sky130_fd_sc_hd__fill_1
XTAP_TAPCELL_ROW_51_930 VGND VPWR sky130_fd_sc_hd__tapvpwrvgnd_1
XFILLER_12_125 VGND VGND VPWR VPWR sky130_fd_sc_hd__decap_3
XFILLER_13_659 VGND VGND VPWR VPWR sky130_fd_sc_hd__decap_3
XFILLER_12_136 VGND VGND VPWR VPWR sky130_fd_sc_hd__decap_3
XFILLER_40_456 VGND VGND VPWR VPWR sky130_fd_sc_hd__decap_3
XFILLER_40_489 VGND VGND VPWR VPWR sky130_fd_sc_hd__decap_3
XFILLER_4_324 VGND VGND VPWR VPWR sky130_fd_sc_hd__decap_3
XFILLER_119_591 VGND VGND VPWR VPWR sky130_fd_sc_hd__decap_3
XFILLER_122_701 VGND VGND VPWR VPWR sky130_fd_sc_hd__decap_3
XFILLER_106_274 VGND VGND VPWR VPWR sky130_fd_sc_hd__decap_3
XFILLER_79_125 VGND VGND VPWR VPWR sky130_fd_sc_hd__decap_3
XFILLER_79_169 VGND VGND VPWR VPWR sky130_fd_sc_hd__decap_3
XFILLER_95_629 VGND VGND VPWR VPWR sky130_fd_sc_hd__decap_3
XFILLER_88_681 VGND VGND VPWR VPWR sky130_fd_sc_hd__decap_3
XFILLER_121_299 VGND VGND VPWR VPWR sky130_fd_sc_hd__decap_3
XFILLER_57_51 VGND VGND VPWR VPWR sky130_fd_sc_hd__decap_3
XFILLER_102_480 VGND VGND VPWR VPWR sky130_fd_sc_hd__fill_2
XFILLER_87_191 VGND VGND VPWR VPWR sky130_fd_sc_hd__decap_3
XFILLER_36_707 VGND VGND VPWR VPWR sky130_fd_sc_hd__decap_3
XFILLER_48_567 VGND VGND VPWR VPWR sky130_fd_sc_hd__decap_3
XFILLER_75_375 VGND VGND VPWR VPWR sky130_fd_sc_hd__fill_2
XFILLER_75_386 VGND VGND VPWR VPWR sky130_fd_sc_hd__decap_3
XFILLER_35_228 VGND VGND VPWR VPWR sky130_fd_sc_hd__decap_3
XFILLER_28_280 VGND VGND VPWR VPWR sky130_fd_sc_hd__decap_3
XFILLER_90_345 VGND VGND VPWR VPWR sky130_fd_sc_hd__fill_1
XFILLER_113_90 VGND VGND VPWR VPWR sky130_fd_sc_hd__decap_3
XFILLER_50_209 VGND VGND VPWR VPWR sky130_fd_sc_hd__decap_3
XFILLER_43_272 VGND VGND VPWR VPWR sky130_fd_sc_hd__fill_1
XFILLER_31_412 VGND VGND VPWR VPWR sky130_fd_sc_hd__decap_3
XFILLER_71_592 VGND VGND VPWR VPWR sky130_fd_sc_hd__decap_3
XFILLER_85_6 VGND VGND VPWR VPWR sky130_fd_sc_hd__decap_3
XFILLER_12_681 VGND VGND VPWR VPWR sky130_fd_sc_hd__decap_3
XFILLER_8_663 VGND VGND VPWR VPWR sky130_fd_sc_hd__decap_3
XFILLER_117_517 VGND VGND VPWR VPWR sky130_fd_sc_hd__decap_3
XFILLER_7_151 VGND VGND VPWR VPWR sky130_fd_sc_hd__decap_3
X_4440_ _4440_/A _4650_/B VGND VGND VPWR VPWR _4441_/B sky130_fd_sc_hd__nand2_2
XFILLER_8_696 VGND VGND VPWR VPWR sky130_fd_sc_hd__decap_3
XFILLER_7_184 VGND VGND VPWR VPWR sky130_fd_sc_hd__decap_3
X_4371_ _4371_/A _4371_/B VGND VGND VPWR VPWR _4371_/Y sky130_fd_sc_hd__nand2_2
XFILLER_113_712 VGND VGND VPWR VPWR sky130_fd_sc_hd__decap_3
X_7090_ _7313_/CLK _7090_/D _6370_/Y VGND VGND VPWR VPWR _7090_/Q sky130_fd_sc_hd__dfrtp_2
XFILLER_98_445 VGND VGND VPWR VPWR sky130_fd_sc_hd__decap_3
XFILLER_112_233 VGND VGND VPWR VPWR sky130_fd_sc_hd__decap_3
XFILLER_86_607 VGND VGND VPWR VPWR sky130_fd_sc_hd__decap_3
XFILLER_58_309 VGND VGND VPWR VPWR sky130_fd_sc_hd__decap_3
XFILLER_85_106 VGND VGND VPWR VPWR sky130_fd_sc_hd__decap_3
XFILLER_112_277 VGND VGND VPWR VPWR sky130_fd_sc_hd__decap_3
XFILLER_100_417 VGND VGND VPWR VPWR sky130_fd_sc_hd__decap_3
XFILLER_78_180 VGND VGND VPWR VPWR sky130_fd_sc_hd__decap_3
XFILLER_94_640 VGND VGND VPWR VPWR sky130_fd_sc_hd__decap_3
XFILLER_94_651 VGND VGND VPWR VPWR sky130_fd_sc_hd__decap_3
XFILLER_39_556 VGND VGND VPWR VPWR sky130_fd_sc_hd__decap_3
XFILLER_27_718 VGND VGND VPWR VPWR sky130_fd_sc_hd__decap_3
XFILLER_27_729 VGND VGND VPWR VPWR sky130_fd_sc_hd__decap_3
XFILLER_94_684 VGND VGND VPWR VPWR sky130_fd_sc_hd__decap_3
XFILLER_81_301 VGND VGND VPWR VPWR sky130_fd_sc_hd__decap_3
XFILLER_54_526 VGND VGND VPWR VPWR sky130_fd_sc_hd__decap_3
XFILLER_26_217 VGND VGND VPWR VPWR sky130_fd_sc_hd__decap_3
XFILLER_54_548 VGND VGND VPWR VPWR sky130_fd_sc_hd__decap_3
XTAP_TAPCELL_ROW_37_746 VGND VPWR sky130_fd_sc_hd__tapvpwrvgnd_1
X_6943_ _7371_/CLK _6943_/D VGND VGND VPWR VPWR _6943_/Q sky130_fd_sc_hd__dfxtp_2
XFILLER_93_194 VGND VGND VPWR VPWR sky130_fd_sc_hd__decap_3
X_6874_ _7378_/CLK _6874_/D VGND VGND VPWR VPWR _6874_/Q sky130_fd_sc_hd__dfxtp_2
XFILLER_50_710 VGND VGND VPWR VPWR sky130_fd_sc_hd__decap_3
XFILLER_62_592 VGND VGND VPWR VPWR sky130_fd_sc_hd__fill_1
XFILLER_34_294 VGND VGND VPWR VPWR sky130_fd_sc_hd__decap_3
XTAP_TAPCELL_ROW_17_492 VGND VPWR sky130_fd_sc_hd__tapvpwrvgnd_1
XFILLER_22_467 VGND VGND VPWR VPWR sky130_fd_sc_hd__fill_1
XFILLER_10_607 VGND VGND VPWR VPWR sky130_fd_sc_hd__decap_3
XFILLER_22_489 VGND VGND VPWR VPWR sky130_fd_sc_hd__decap_3
X_4707_ _6998_/Q _6999_/Q _7000_/Q _4912_/A VGND VGND VPWR VPWR _4825_/B sky130_fd_sc_hd__and4_2
XFILLER_108_539 VGND VGND VPWR VPWR sky130_fd_sc_hd__decap_3
X_4638_ _4950_/A _4950_/B VGND VGND VPWR VPWR _4948_/B sky130_fd_sc_hd__and2_2
XFILLER_118_24 VGND VGND VPWR VPWR sky130_fd_sc_hd__decap_3
XFILLER_118_35 VGND VGND VPWR VPWR sky130_fd_sc_hd__decap_3
Xhold630 _6749_/Q VGND VGND VPWR VPWR _6749_/D sky130_fd_sc_hd__dlygate4sd3_1
X_7357_ _7392_/CLK _7357_/D _6637_/Y VGND VGND VPWR VPWR _7357_/Q sky130_fd_sc_hd__dfrtp_2
XFILLER_118_68 VGND VGND VPWR VPWR sky130_fd_sc_hd__decap_3
XFILLER_104_701 VGND VGND VPWR VPWR sky130_fd_sc_hd__decap_3
X_4569_ _4569_/A _4577_/B VGND VGND VPWR VPWR _7296_/D sky130_fd_sc_hd__and2_2
Xhold641 _6866_/Q VGND VGND VPWR VPWR _6866_/D sky130_fd_sc_hd__dlygate4sd3_1
Xhold652 _6881_/Q VGND VGND VPWR VPWR _6881_/D sky130_fd_sc_hd__dlygate4sd3_1
XFILLER_116_572 VGND VGND VPWR VPWR sky130_fd_sc_hd__decap_3
Xhold663 _6955_/Q VGND VGND VPWR VPWR _6955_/D sky130_fd_sc_hd__dlygate4sd3_1
X_6308_ _6658_/A VGND VGND VPWR VPWR _6308_/Y sky130_fd_sc_hd__inv_2
Xhold674 _6934_/Q VGND VGND VPWR VPWR _6934_/D sky130_fd_sc_hd__dlygate4sd3_1
XFILLER_104_734 VGND VGND VPWR VPWR sky130_fd_sc_hd__fill_1
Xhold685 _6876_/Q VGND VGND VPWR VPWR _6876_/D sky130_fd_sc_hd__dlygate4sd3_1
X_7288_ _7354_/CLK _7288_/D _6568_/Y VGND VGND VPWR VPWR _7288_/Q sky130_fd_sc_hd__dfrtp_2
XFILLER_89_445 VGND VGND VPWR VPWR sky130_fd_sc_hd__decap_3
XFILLER_103_222 VGND VGND VPWR VPWR sky130_fd_sc_hd__fill_2
Xhold696 _6767_/Q VGND VGND VPWR VPWR _6767_/D sky130_fd_sc_hd__dlygate4sd3_1
XFILLER_89_467 VGND VGND VPWR VPWR sky130_fd_sc_hd__decap_3
XFILLER_103_255 VGND VGND VPWR VPWR sky130_fd_sc_hd__decap_3
XFILLER_77_629 VGND VGND VPWR VPWR sky130_fd_sc_hd__decap_3
XFILLER_103_299 VGND VGND VPWR VPWR sky130_fd_sc_hd__decap_3
XFILLER_57_320 VGND VGND VPWR VPWR sky130_fd_sc_hd__decap_3
XFILLER_18_707 VGND VGND VPWR VPWR sky130_fd_sc_hd__decap_3
XFILLER_91_109 VGND VGND VPWR VPWR sky130_fd_sc_hd__decap_3
XFILLER_85_662 VGND VGND VPWR VPWR sky130_fd_sc_hd__decap_3
XFILLER_85_673 VGND VGND VPWR VPWR sky130_fd_sc_hd__decap_3
XFILLER_84_150 VGND VGND VPWR VPWR sky130_fd_sc_hd__decap_3
XFILLER_57_364 VGND VGND VPWR VPWR sky130_fd_sc_hd__fill_1
XFILLER_57_386 VGND VGND VPWR VPWR sky130_fd_sc_hd__decap_3
XFILLER_17_228 VGND VGND VPWR VPWR sky130_fd_sc_hd__decap_3
XFILLER_25_250 VGND VGND VPWR VPWR sky130_fd_sc_hd__decap_3
XFILLER_60_529 VGND VGND VPWR VPWR sky130_fd_sc_hd__decap_3
XFILLER_53_570 VGND VGND VPWR VPWR sky130_fd_sc_hd__decap_3
XFILLER_25_261 VGND VGND VPWR VPWR sky130_fd_sc_hd__decap_3
XFILLER_41_721 VGND VGND VPWR VPWR sky130_fd_sc_hd__decap_3
XFILLER_41_732 VGND VGND VPWR VPWR sky130_fd_sc_hd__decap_3
XFILLER_40_220 VGND VGND VPWR VPWR sky130_fd_sc_hd__decap_3
XFILLER_13_445 VGND VGND VPWR VPWR sky130_fd_sc_hd__decap_3
XFILLER_40_253 VGND VGND VPWR VPWR sky130_fd_sc_hd__decap_3
XFILLER_9_449 VGND VGND VPWR VPWR sky130_fd_sc_hd__decap_3
XTAP_TAPCELL_ROW_97_1523 VGND VPWR sky130_fd_sc_hd__tapvpwrvgnd_1
XTAP_TAPCELL_ROW_97_1534 VGND VPWR sky130_fd_sc_hd__tapvpwrvgnd_1
XFILLER_5_600 VGND VGND VPWR VPWR sky130_fd_sc_hd__decap_3
XFILLER_5_644 VGND VGND VPWR VPWR sky130_fd_sc_hd__decap_3
XFILLER_4_121 VGND VGND VPWR VPWR sky130_fd_sc_hd__fill_2
XFILLER_107_550 VGND VGND VPWR VPWR sky130_fd_sc_hd__decap_3
XFILLER_107_561 VGND VGND VPWR VPWR sky130_fd_sc_hd__decap_3
XFILLER_5_688 VGND VGND VPWR VPWR sky130_fd_sc_hd__decap_3
XFILLER_4_14 VGND VGND VPWR VPWR sky130_fd_sc_hd__decap_3
XFILLER_107_594 VGND VGND VPWR VPWR sky130_fd_sc_hd__decap_3
XFILLER_122_531 VGND VGND VPWR VPWR sky130_fd_sc_hd__fill_1
XFILLER_122_542 VGND VGND VPWR VPWR sky130_fd_sc_hd__decap_3
XFILLER_68_607 VGND VGND VPWR VPWR sky130_fd_sc_hd__decap_3
XFILLER_68_50 VGND VGND VPWR VPWR sky130_fd_sc_hd__decap_3
XFILLER_110_704 VGND VGND VPWR VPWR sky130_fd_sc_hd__decap_3
XFILLER_67_106 VGND VGND VPWR VPWR sky130_fd_sc_hd__decap_3
XFILLER_122_575 VGND VGND VPWR VPWR sky130_fd_sc_hd__decap_3
XFILLER_95_426 VGND VGND VPWR VPWR sky130_fd_sc_hd__decap_3
XFILLER_0_393 VGND VGND VPWR VPWR sky130_fd_sc_hd__decap_3
XFILLER_76_640 VGND VGND VPWR VPWR sky130_fd_sc_hd__decap_3
XFILLER_76_651 VGND VGND VPWR VPWR sky130_fd_sc_hd__decap_3
XFILLER_48_342 VGND VGND VPWR VPWR sky130_fd_sc_hd__fill_1
XFILLER_76_684 VGND VGND VPWR VPWR sky130_fd_sc_hd__decap_3
XFILLER_75_150 VGND VGND VPWR VPWR sky130_fd_sc_hd__decap_3
XFILLER_75_172 VGND VGND VPWR VPWR sky130_fd_sc_hd__decap_3
XFILLER_91_632 VGND VGND VPWR VPWR sky130_fd_sc_hd__decap_3
XFILLER_63_323 VGND VGND VPWR VPWR sky130_fd_sc_hd__decap_3
XFILLER_84_71 VGND VGND VPWR VPWR sky130_fd_sc_hd__decap_3
Xplace301 _3889_/A2 VGND VGND VPWR VPWR _3913_/A2 sky130_fd_sc_hd__buf_2
XFILLER_90_120 VGND VGND VPWR VPWR sky130_fd_sc_hd__decap_3
Xplace312 _4764_/Y VGND VGND VPWR VPWR _4788_/A sky130_fd_sc_hd__buf_2
XFILLER_90_131 VGND VGND VPWR VPWR sky130_fd_sc_hd__decap_3
XTAP_TAPCELL_ROW_106_1641 VGND VPWR sky130_fd_sc_hd__tapvpwrvgnd_1
Xplace323 _3424_/S VGND VGND VPWR VPWR _4327_/A sky130_fd_sc_hd__buf_2
XFILLER_91_665 VGND VGND VPWR VPWR sky130_fd_sc_hd__decap_3
Xplace334 _5708_/S VGND VGND VPWR VPWR _5737_/S sky130_fd_sc_hd__buf_2
XFILLER_91_676 VGND VGND VPWR VPWR sky130_fd_sc_hd__decap_3
XFILLER_90_153 VGND VGND VPWR VPWR sky130_fd_sc_hd__decap_3
XTAP_TAPCELL_ROW_34_705 VGND VPWR sky130_fd_sc_hd__tapvpwrvgnd_1
Xplace345 _5429_/S VGND VGND VPWR VPWR _5398_/S sky130_fd_sc_hd__buf_2
XFILLER_51_518 VGND VGND VPWR VPWR sky130_fd_sc_hd__decap_3
Xplace356 _5140_/S VGND VGND VPWR VPWR _5157_/S sky130_fd_sc_hd__buf_2
XFILLER_32_710 VGND VGND VPWR VPWR sky130_fd_sc_hd__decap_3
Xplace367 _4305_/B VGND VGND VPWR VPWR _4265_/B sky130_fd_sc_hd__buf_2
XFILLER_16_272 VGND VGND VPWR VPWR sky130_fd_sc_hd__decap_3
Xplace378 _3469_/A VGND VGND VPWR VPWR _3991_/A sky130_fd_sc_hd__buf_2
XFILLER_90_197 VGND VGND VPWR VPWR sky130_fd_sc_hd__decap_3
Xplace389 _5225_/B VGND VGND VPWR VPWR _5200_/B sky130_fd_sc_hd__buf_2
XFILLER_31_220 VGND VGND VPWR VPWR sky130_fd_sc_hd__decap_3
X_3871_ _6785_/Q _3913_/A2 _3871_/B1 _6873_/Q VGND VGND VPWR VPWR _3871_/X sky130_fd_sc_hd__a22o_2
XFILLER_31_231 VGND VGND VPWR VPWR sky130_fd_sc_hd__decap_3
XTAP_TAPCELL_ROW_14_451 VGND VPWR sky130_fd_sc_hd__tapvpwrvgnd_1
X_6590_ _6622_/A VGND VGND VPWR VPWR _6590_/Y sky130_fd_sc_hd__inv_2
XFILLER_83_3 VGND VGND VPWR VPWR sky130_fd_sc_hd__decap_3
XFILLER_117_303 VGND VGND VPWR VPWR sky130_fd_sc_hd__decap_3
XFILLER_117_325 VGND VGND VPWR VPWR sky130_fd_sc_hd__decap_3
XTAP_TAPCELL_ROW_57_1006 VGND VPWR sky130_fd_sc_hd__tapvpwrvgnd_1
X_7211_ _7404_/CLK _7211_/D _6491_/Y VGND VGND VPWR VPWR _7211_/Q sky130_fd_sc_hd__dfrtp_2
X_4423_ _7080_/Q _4102_/B _4432_/B1 _4422_/X VGND VGND VPWR VPWR _4649_/B sky130_fd_sc_hd__o211ai_2
XFILLER_99_721 VGND VGND VPWR VPWR sky130_fd_sc_hd__decap_3
XTAP_TAPCELL_ROW_117_1792 VGND VPWR sky130_fd_sc_hd__tapvpwrvgnd_1
XFILLER_99_732 VGND VGND VPWR VPWR sky130_fd_sc_hd__decap_3
X_7142_ _7368_/CLK _7142_/D _6422_/Y VGND VGND VPWR VPWR _7142_/Q sky130_fd_sc_hd__dfrtp_2
XFILLER_113_520 VGND VGND VPWR VPWR sky130_fd_sc_hd__decap_3
X_4354_ _7038_/Q _3488_/B _4354_/B1 _7385_/Q VGND VGND VPWR VPWR _4355_/B sky130_fd_sc_hd__a22o_2
XFILLER_98_253 VGND VGND VPWR VPWR sky130_fd_sc_hd__decap_3
XFILLER_113_553 VGND VGND VPWR VPWR sky130_fd_sc_hd__decap_3
X_3305_ _5670_/A VGND VGND VPWR VPWR _3340_/B sky130_fd_sc_hd__inv_2
XFILLER_113_564 VGND VGND VPWR VPWR sky130_fd_sc_hd__decap_3
X_7073_ _7398_/CLK _7073_/D _6353_/Y VGND VGND VPWR VPWR _7073_/Q sky130_fd_sc_hd__dfrtp_2
XFILLER_59_629 VGND VGND VPWR VPWR sky130_fd_sc_hd__decap_3
XFILLER_101_715 VGND VGND VPWR VPWR sky130_fd_sc_hd__decap_3
X_4285_ _7035_/Q _3488_/B _4354_/B1 _7382_/Q VGND VGND VPWR VPWR _4286_/B sky130_fd_sc_hd__a22o_2
XFILLER_100_203 VGND VGND VPWR VPWR sky130_fd_sc_hd__decap_3
XFILLER_113_597 VGND VGND VPWR VPWR sky130_fd_sc_hd__decap_3
XFILLER_86_448 VGND VGND VPWR VPWR sky130_fd_sc_hd__decap_3
XFILLER_39_320 VGND VGND VPWR VPWR sky130_fd_sc_hd__decap_3
XFILLER_100_236 VGND VGND VPWR VPWR sky130_fd_sc_hd__decap_3
XFILLER_67_662 VGND VGND VPWR VPWR sky130_fd_sc_hd__decap_3
XFILLER_73_109 VGND VGND VPWR VPWR sky130_fd_sc_hd__decap_3
XFILLER_67_673 VGND VGND VPWR VPWR sky130_fd_sc_hd__decap_3
XFILLER_82_610 VGND VGND VPWR VPWR sky130_fd_sc_hd__decap_3
XFILLER_54_312 VGND VGND VPWR VPWR sky130_fd_sc_hd__decap_3
XTAP_TAPCELL_ROW_68_1146 VGND VPWR sky130_fd_sc_hd__tapvpwrvgnd_1
XFILLER_82_643 VGND VGND VPWR VPWR sky130_fd_sc_hd__fill_1
XFILLER_66_194 VGND VGND VPWR VPWR sky130_fd_sc_hd__fill_2
XFILLER_82_654 VGND VGND VPWR VPWR sky130_fd_sc_hd__decap_3
XFILLER_54_345 VGND VGND VPWR VPWR sky130_fd_sc_hd__decap_3
XTAP_TAPCELL_ROW_68_1157 VGND VPWR sky130_fd_sc_hd__tapvpwrvgnd_1
XFILLER_82_687 VGND VGND VPWR VPWR sky130_fd_sc_hd__decap_3
XFILLER_81_153 VGND VGND VPWR VPWR sky130_fd_sc_hd__decap_3
XFILLER_54_378 VGND VGND VPWR VPWR sky130_fd_sc_hd__decap_3
X_6926_ _6926_/CLK _6926_/D VGND VGND VPWR VPWR _6926_/Q sky130_fd_sc_hd__dfxtp_2
XFILLER_120_14 VGND VGND VPWR VPWR sky130_fd_sc_hd__decap_3
XFILLER_81_186 VGND VGND VPWR VPWR sky130_fd_sc_hd__decap_3
XFILLER_23_721 VGND VGND VPWR VPWR sky130_fd_sc_hd__decap_3
XFILLER_23_732 VGND VGND VPWR VPWR sky130_fd_sc_hd__decap_3
XTAP_TAPCELL_ROW_81_1324 VGND VPWR sky130_fd_sc_hd__tapvpwrvgnd_1
XFILLER_120_47 VGND VGND VPWR VPWR sky130_fd_sc_hd__decap_3
Xfanout24 _6598_/A VGND VGND VPWR VPWR _6630_/A sky130_fd_sc_hd__buf_2
X_6857_ _6926_/CLK _6857_/D VGND VGND VPWR VPWR _6857_/Q sky130_fd_sc_hd__dfxtp_2
Xfanout35 _6637_/A VGND VGND VPWR VPWR _6633_/A sky130_fd_sc_hd__buf_2
Xfanout46 fanout47/X VGND VGND VPWR VPWR fanout46/X sky130_fd_sc_hd__clkdlybuf4s25_1
XFILLER_80_29 VGND VGND VPWR VPWR sky130_fd_sc_hd__fill_2
Xfanout57 _6646_/A VGND VGND VPWR VPWR _6653_/A sky130_fd_sc_hd__clkdlybuf4s25_1
XFILLER_22_253 VGND VGND VPWR VPWR sky130_fd_sc_hd__decap_3
Xfanout68 _6553_/A VGND VGND VPWR VPWR _6651_/A sky130_fd_sc_hd__buf_2
XFILLER_10_404 VGND VGND VPWR VPWR sky130_fd_sc_hd__decap_3
X_6788_ _6926_/CLK _6788_/D VGND VGND VPWR VPWR _6788_/Q sky130_fd_sc_hd__dfxtp_2
XFILLER_50_595 VGND VGND VPWR VPWR sky130_fd_sc_hd__decap_3
XFILLER_22_297 VGND VGND VPWR VPWR sky130_fd_sc_hd__decap_3
XFILLER_10_448 VGND VGND VPWR VPWR sky130_fd_sc_hd__decap_3
XFILLER_89_49 VGND VGND VPWR VPWR sky130_fd_sc_hd__decap_3
XTAP_TAPCELL_ROW_79_1297 VGND VPWR sky130_fd_sc_hd__tapvpwrvgnd_1
XFILLER_123_317 VGND VGND VPWR VPWR sky130_fd_sc_hd__decap_3
XFILLER_2_614 VGND VGND VPWR VPWR sky130_fd_sc_hd__decap_3
XFILLER_1_113 VGND VGND VPWR VPWR sky130_fd_sc_hd__fill_1
XFILLER_89_231 VGND VGND VPWR VPWR sky130_fd_sc_hd__decap_3
XTAP_TAPCELL_ROW_92_1464 VGND VPWR sky130_fd_sc_hd__tapvpwrvgnd_1
XFILLER_104_542 VGND VGND VPWR VPWR sky130_fd_sc_hd__decap_3
XFILLER_2_669 VGND VGND VPWR VPWR sky130_fd_sc_hd__decap_3
XFILLER_89_264 VGND VGND VPWR VPWR sky130_fd_sc_hd__decap_3
XFILLER_104_575 VGND VGND VPWR VPWR sky130_fd_sc_hd__decap_3
XFILLER_77_426 VGND VGND VPWR VPWR sky130_fd_sc_hd__fill_2
XFILLER_58_651 VGND VGND VPWR VPWR sky130_fd_sc_hd__decap_3
XFILLER_92_407 VGND VGND VPWR VPWR sky130_fd_sc_hd__decap_3
XFILLER_92_429 VGND VGND VPWR VPWR sky130_fd_sc_hd__decap_3
XFILLER_58_684 VGND VGND VPWR VPWR sky130_fd_sc_hd__decap_3
XFILLER_57_161 VGND VGND VPWR VPWR sky130_fd_sc_hd__decap_3
Xhold1160 _7270_/Q VGND VGND VPWR VPWR _4865_/A0 sky130_fd_sc_hd__dlygate4sd3_1
Xhold1171 _7337_/Q VGND VGND VPWR VPWR _4484_/A0 sky130_fd_sc_hd__dlygate4sd3_1
Xhold1182 _7178_/Q VGND VGND VPWR VPWR _5304_/A0 sky130_fd_sc_hd__dlygate4sd3_1
XFILLER_73_632 VGND VGND VPWR VPWR sky130_fd_sc_hd__decap_3
XFILLER_57_194 VGND VGND VPWR VPWR sky130_fd_sc_hd__decap_3
Xhold1193 _7302_/Q VGND VGND VPWR VPWR _4556_/A sky130_fd_sc_hd__dlygate4sd3_1
XFILLER_73_665 VGND VGND VPWR VPWR sky130_fd_sc_hd__decap_3
XFILLER_73_676 VGND VGND VPWR VPWR sky130_fd_sc_hd__decap_3
XFILLER_72_153 VGND VGND VPWR VPWR sky130_fd_sc_hd__decap_3
XFILLER_45_389 VGND VGND VPWR VPWR sky130_fd_sc_hd__decap_3
XFILLER_14_710 VGND VGND VPWR VPWR sky130_fd_sc_hd__decap_3
XFILLER_60_326 VGND VGND VPWR VPWR sky130_fd_sc_hd__decap_3
XFILLER_26_592 VGND VGND VPWR VPWR sky130_fd_sc_hd__decap_3
XFILLER_60_359 VGND VGND VPWR VPWR sky130_fd_sc_hd__decap_3
XFILLER_13_231 VGND VGND VPWR VPWR sky130_fd_sc_hd__decap_3
XFILLER_9_213 VGND VGND VPWR VPWR sky130_fd_sc_hd__decap_3
XFILLER_13_275 VGND VGND VPWR VPWR sky130_fd_sc_hd__decap_3
XFILLER_41_595 VGND VGND VPWR VPWR sky130_fd_sc_hd__decap_3
XTAP_TAPCELL_ROW_11_410 VGND VPWR sky130_fd_sc_hd__tapvpwrvgnd_1
XFILLER_9_257 VGND VGND VPWR VPWR sky130_fd_sc_hd__decap_3
XTAP_TAPCELL_ROW_101_1582 VGND VPWR sky130_fd_sc_hd__tapvpwrvgnd_1
Xclkload16 _7387_/CLK VGND VGND VPWR VPWR clkload16/Y sky130_fd_sc_hd__inv_6
Xclkload27 _7404_/CLK VGND VGND VPWR VPWR clkload27/Y sky130_fd_sc_hd__clkinv_4
XFILLER_114_306 VGND VGND VPWR VPWR sky130_fd_sc_hd__fill_2
XFILLER_114_317 VGND VGND VPWR VPWR sky130_fd_sc_hd__decap_3
XFILLER_79_60 VGND VGND VPWR VPWR sky130_fd_sc_hd__decap_3
XFILLER_114_339 VGND VGND VPWR VPWR sky130_fd_sc_hd__decap_3
XFILLER_107_391 VGND VGND VPWR VPWR sky130_fd_sc_hd__fill_1
XFILLER_96_713 VGND VGND VPWR VPWR sky130_fd_sc_hd__decap_3
XFILLER_122_361 VGND VGND VPWR VPWR sky130_fd_sc_hd__decap_3
XFILLER_68_448 VGND VGND VPWR VPWR sky130_fd_sc_hd__decap_3
XFILLER_1_691 VGND VGND VPWR VPWR sky130_fd_sc_hd__decap_3
X_4070_ _7339_/Q _3945_/S _4428_/B1 _7147_/Q VGND VGND VPWR VPWR _4070_/X sky130_fd_sc_hd__a22o_2
XFILLER_110_545 VGND VGND VPWR VPWR sky130_fd_sc_hd__decap_3
XFILLER_49_662 VGND VGND VPWR VPWR sky130_fd_sc_hd__decap_3
XFILLER_110_578 VGND VGND VPWR VPWR sky130_fd_sc_hd__decap_3
XFILLER_49_673 VGND VGND VPWR VPWR sky130_fd_sc_hd__decap_3
XFILLER_110_589 VGND VGND VPWR VPWR sky130_fd_sc_hd__decap_3
XFILLER_64_610 VGND VGND VPWR VPWR sky130_fd_sc_hd__decap_3
XFILLER_76_481 VGND VGND VPWR VPWR sky130_fd_sc_hd__fill_1
XFILLER_48_172 VGND VGND VPWR VPWR sky130_fd_sc_hd__decap_3
XFILLER_36_312 VGND VGND VPWR VPWR sky130_fd_sc_hd__decap_3
XTAP_TAPCELL_ROW_19_510 VGND VPWR sky130_fd_sc_hd__tapvpwrvgnd_1
XFILLER_64_643 VGND VGND VPWR VPWR sky130_fd_sc_hd__fill_1
XFILLER_64_654 VGND VGND VPWR VPWR sky130_fd_sc_hd__decap_3
XTAP_TAPCELL_ROW_47_874 VGND VPWR sky130_fd_sc_hd__tapvpwrvgnd_1
XFILLER_91_473 VGND VGND VPWR VPWR sky130_fd_sc_hd__decap_3
XFILLER_64_687 VGND VGND VPWR VPWR sky130_fd_sc_hd__decap_3
XFILLER_63_164 VGND VGND VPWR VPWR sky130_fd_sc_hd__decap_3
X_4972_ _5661_/B VGND VGND VPWR VPWR _4973_/B sky130_fd_sc_hd__inv_2
XFILLER_63_175 VGND VGND VPWR VPWR sky130_fd_sc_hd__decap_3
XFILLER_17_570 VGND VGND VPWR VPWR sky130_fd_sc_hd__decap_3
XFILLER_51_337 VGND VGND VPWR VPWR sky130_fd_sc_hd__decap_3
X_6711_ _7371_/CLK _6711_/D VGND VGND VPWR VPWR _6711_/Q sky130_fd_sc_hd__dfxtp_2
X_3923_ _3923_/A1 _3922_/X _5104_/A VGND VGND VPWR VPWR _3923_/X sky130_fd_sc_hd__a21o_2
XFILLER_20_713 VGND VGND VPWR VPWR sky130_fd_sc_hd__decap_3
X_6642_ _6642_/A VGND VGND VPWR VPWR _6642_/Y sky130_fd_sc_hd__inv_2
X_3854_ _3725_/X _3851_/X _3853_/X _3735_/X VGND VGND VPWR VPWR _3854_/X sky130_fd_sc_hd__a22o_2
XTAP_TAPCELL_ROW_63_1087 VGND VPWR sky130_fd_sc_hd__tapvpwrvgnd_1
XFILLER_32_595 VGND VGND VPWR VPWR sky130_fd_sc_hd__decap_3
XTAP_TAPCELL_ROW_119_1810 VGND VPWR sky130_fd_sc_hd__tapvpwrvgnd_1
X_6573_ _6638_/A VGND VGND VPWR VPWR _6573_/Y sky130_fd_sc_hd__inv_2
XFILLER_118_601 VGND VGND VPWR VPWR sky130_fd_sc_hd__decap_3
X_3785_ _6837_/Q _3840_/A2 _3656_/Y _6832_/Q _3784_/X VGND VGND VPWR VPWR _3785_/X
+ sky130_fd_sc_hd__a221o_2
XFILLER_118_634 VGND VGND VPWR VPWR sky130_fd_sc_hd__decap_3
XFILLER_117_111 VGND VGND VPWR VPWR sky130_fd_sc_hd__fill_1
XFILLER_118_645 VGND VGND VPWR VPWR sky130_fd_sc_hd__decap_3
XFILLER_118_678 VGND VGND VPWR VPWR sky130_fd_sc_hd__decap_3
XFILLER_105_306 VGND VGND VPWR VPWR sky130_fd_sc_hd__decap_3
Xoutput510 _4671_/B VGND VGND VPWR VPWR instruction_out[28] sky130_fd_sc_hd__clkdlybuf4s25_1
Xoutput521 _6987_/Q VGND VGND VPWR VPWR pc_out[10] sky130_fd_sc_hd__clkdlybuf4s25_1
XFILLER_117_188 VGND VGND VPWR VPWR sky130_fd_sc_hd__decap_3
Xoutput532 _6997_/Q VGND VGND VPWR VPWR pc_out[20] sky130_fd_sc_hd__clkdlybuf4s25_1
X_4406_ _7402_/Q _4437_/B1 _4434_/B1 _7146_/Q _4405_/X VGND VGND VPWR VPWR _4406_/X
+ sky130_fd_sc_hd__a221o_2
Xoutput543 _7007_/Q VGND VGND VPWR VPWR pc_out[30] sky130_fd_sc_hd__clkdlybuf4s25_1
X_5386_ _5386_/A0 _4899_/X _5398_/S VGND VGND VPWR VPWR _7140_/D sky130_fd_sc_hd__mux2_2
XFILLER_120_309 VGND VGND VPWR VPWR sky130_fd_sc_hd__fill_2
X_7125_ _7279_/CLK _7125_/D _6405_/Y VGND VGND VPWR VPWR _7125_/Q sky130_fd_sc_hd__dfrtp_2
XFILLER_99_573 VGND VGND VPWR VPWR sky130_fd_sc_hd__decap_3
X_4337_ _4394_/A _4337_/B _4336_/X VGND VGND VPWR VPWR _4365_/C sky130_fd_sc_hd__or3b_2
XFILLER_87_724 VGND VGND VPWR VPWR sky130_fd_sc_hd__decap_3
XFILLER_101_501 VGND VGND VPWR VPWR sky130_fd_sc_hd__decap_3
XFILLER_86_212 VGND VGND VPWR VPWR sky130_fd_sc_hd__decap_3
XFILLER_59_426 VGND VGND VPWR VPWR sky130_fd_sc_hd__fill_2
XFILLER_115_25 VGND VGND VPWR VPWR sky130_fd_sc_hd__decap_3
X_7056_ _7279_/CLK _7056_/D _6336_/Y VGND VGND VPWR VPWR _7056_/Q sky130_fd_sc_hd__dfstp_2
X_4268_ _7198_/Q _3966_/S _4268_/B1 _7390_/Q VGND VGND VPWR VPWR _4268_/X sky130_fd_sc_hd__a22o_2
XFILLER_86_245 VGND VGND VPWR VPWR sky130_fd_sc_hd__decap_3
XFILLER_115_69 VGND VGND VPWR VPWR sky130_fd_sc_hd__decap_3
XFILLER_86_256 VGND VGND VPWR VPWR sky130_fd_sc_hd__decap_3
XFILLER_75_18 VGND VGND VPWR VPWR sky130_fd_sc_hd__decap_3
XFILLER_101_567 VGND VGND VPWR VPWR sky130_fd_sc_hd__decap_3
X_4199_ _4380_/A _4380_/B VGND VGND VPWR VPWR _4381_/A sky130_fd_sc_hd__nand2_2
XFILLER_55_632 VGND VGND VPWR VPWR sky130_fd_sc_hd__decap_3
XFILLER_27_323 VGND VGND VPWR VPWR sky130_fd_sc_hd__decap_3
XFILLER_54_120 VGND VGND VPWR VPWR sky130_fd_sc_hd__decap_3
XFILLER_39_194 VGND VGND VPWR VPWR sky130_fd_sc_hd__decap_3
XFILLER_55_665 VGND VGND VPWR VPWR sky130_fd_sc_hd__decap_3
XFILLER_55_676 VGND VGND VPWR VPWR sky130_fd_sc_hd__decap_3
XFILLER_70_613 VGND VGND VPWR VPWR sky130_fd_sc_hd__decap_3
XFILLER_42_304 VGND VGND VPWR VPWR sky130_fd_sc_hd__decap_3
XFILLER_15_529 VGND VGND VPWR VPWR sky130_fd_sc_hd__decap_3
XFILLER_82_495 VGND VGND VPWR VPWR sky130_fd_sc_hd__fill_1
XFILLER_42_326 VGND VGND VPWR VPWR sky130_fd_sc_hd__fill_1
XFILLER_70_657 VGND VGND VPWR VPWR sky130_fd_sc_hd__decap_3
X_6909_ clkload4/A _6909_/D VGND VGND VPWR VPWR _6909_/Q sky130_fd_sc_hd__dfxtp_2
XPHY_EDGE_ROW_59_Left_183 VGND VGND VPWR VPWR sky130_fd_sc_hd__decap_3
XFILLER_11_724 VGND VGND VPWR VPWR sky130_fd_sc_hd__decap_3
XFILLER_23_595 VGND VGND VPWR VPWR sky130_fd_sc_hd__decap_3
XFILLER_50_381 VGND VGND VPWR VPWR sky130_fd_sc_hd__fill_1
XFILLER_10_223 VGND VGND VPWR VPWR sky130_fd_sc_hd__decap_3
XFILLER_7_706 VGND VGND VPWR VPWR sky130_fd_sc_hd__decap_3
XFILLER_10_256 VGND VGND VPWR VPWR sky130_fd_sc_hd__decap_3
XFILLER_109_612 VGND VGND VPWR VPWR sky130_fd_sc_hd__decap_3
XFILLER_109_623 VGND VGND VPWR VPWR sky130_fd_sc_hd__decap_3
XFILLER_6_238 VGND VGND VPWR VPWR sky130_fd_sc_hd__fill_1
XFILLER_108_122 VGND VGND VPWR VPWR sky130_fd_sc_hd__decap_3
XFILLER_109_656 VGND VGND VPWR VPWR sky130_fd_sc_hd__decap_3
XFILLER_40_65 VGND VGND VPWR VPWR sky130_fd_sc_hd__decap_3
XFILLER_108_144 VGND VGND VPWR VPWR sky130_fd_sc_hd__decap_3
XFILLER_123_125 VGND VGND VPWR VPWR sky130_fd_sc_hd__decap_3
XFILLER_2_444 VGND VGND VPWR VPWR sky130_fd_sc_hd__fill_2
XPHY_EDGE_ROW_68_Left_192 VGND VGND VPWR VPWR sky130_fd_sc_hd__decap_3
XFILLER_78_713 VGND VGND VPWR VPWR sky130_fd_sc_hd__decap_3
XFILLER_104_350 VGND VGND VPWR VPWR sky130_fd_sc_hd__fill_2
XFILLER_77_223 VGND VGND VPWR VPWR sky130_fd_sc_hd__fill_1
XFILLER_104_383 VGND VGND VPWR VPWR sky130_fd_sc_hd__decap_3
XFILLER_77_245 VGND VGND VPWR VPWR sky130_fd_sc_hd__decap_3
XFILLER_65_407 VGND VGND VPWR VPWR sky130_fd_sc_hd__decap_3
XFILLER_1_15 VGND VGND VPWR VPWR sky130_fd_sc_hd__decap_3
XFILLER_93_727 VGND VGND VPWR VPWR sky130_fd_sc_hd__fill_1
XFILLER_18_312 VGND VGND VPWR VPWR sky130_fd_sc_hd__decap_3
XFILLER_105_80 VGND VGND VPWR VPWR sky130_fd_sc_hd__fill_1
XFILLER_46_632 VGND VGND VPWR VPWR sky130_fd_sc_hd__decap_3
XFILLER_92_259 VGND VGND VPWR VPWR sky130_fd_sc_hd__decap_3
XFILLER_73_440 VGND VGND VPWR VPWR sky130_fd_sc_hd__decap_3
XFILLER_46_654 VGND VGND VPWR VPWR sky130_fd_sc_hd__decap_3
XFILLER_45_153 VGND VGND VPWR VPWR sky130_fd_sc_hd__fill_1
XFILLER_46_687 VGND VGND VPWR VPWR sky130_fd_sc_hd__decap_3
XFILLER_45_175 VGND VGND VPWR VPWR sky130_fd_sc_hd__decap_3
XTAP_TAPCELL_ROW_103_1600 VGND VPWR sky130_fd_sc_hd__tapvpwrvgnd_1
XFILLER_61_635 VGND VGND VPWR VPWR sky130_fd_sc_hd__decap_3
XTAP_TAPCELL_ROW_103_1611 VGND VPWR sky130_fd_sc_hd__tapvpwrvgnd_1
XTAP_TAPCELL_ROW_44_833 VGND VPWR sky130_fd_sc_hd__tapvpwrvgnd_1
XFILLER_60_112 VGND VGND VPWR VPWR sky130_fd_sc_hd__fill_1
XFILLER_33_337 VGND VGND VPWR VPWR sky130_fd_sc_hd__decap_3
XTAP_TAPCELL_ROW_44_844 VGND VPWR sky130_fd_sc_hd__tapvpwrvgnd_1
XFILLER_61_668 VGND VGND VPWR VPWR sky130_fd_sc_hd__decap_3
XFILLER_61_679 VGND VGND VPWR VPWR sky130_fd_sc_hd__decap_3
XFILLER_14_540 VGND VGND VPWR VPWR sky130_fd_sc_hd__decap_3
XFILLER_121_90 VGND VGND VPWR VPWR sky130_fd_sc_hd__decap_3
XFILLER_14_573 VGND VGND VPWR VPWR sky130_fd_sc_hd__decap_3
XFILLER_60_189 VGND VGND VPWR VPWR sky130_fd_sc_hd__decap_3
XFILLER_14_595 VGND VGND VPWR VPWR sky130_fd_sc_hd__decap_3
XFILLER_81_94 VGND VGND VPWR VPWR sky130_fd_sc_hd__fill_2
X_3570_ _7157_/Q _3409_/X _4337_/B _3469_/B _3469_/A VGND VGND VPWR VPWR _3570_/X
+ sky130_fd_sc_hd__a2111o_2
XFILLER_115_615 VGND VGND VPWR VPWR sky130_fd_sc_hd__fill_1
XFILLER_115_626 VGND VGND VPWR VPWR sky130_fd_sc_hd__decap_3
XFILLER_5_260 VGND VGND VPWR VPWR sky130_fd_sc_hd__decap_3
XFILLER_114_114 VGND VGND VPWR VPWR sky130_fd_sc_hd__decap_3
X_5240_ _4788_/A _4788_/B _5238_/X hold983/X VGND VGND VPWR VPWR _7210_/D sky130_fd_sc_hd__a22o_2
XFILLER_115_659 VGND VGND VPWR VPWR sky130_fd_sc_hd__decap_3
XTAP_TAPCELL_ROW_114_1751 VGND VPWR sky130_fd_sc_hd__tapvpwrvgnd_1
XFILLER_5_293 VGND VGND VPWR VPWR sky130_fd_sc_hd__decap_3
XFILLER_46_3 VGND VGND VPWR VPWR sky130_fd_sc_hd__fill_2
XFILLER_114_158 VGND VGND VPWR VPWR sky130_fd_sc_hd__decap_3
XPHY_EDGE_ROW_18_Right_18 VGND VGND VPWR VPWR sky130_fd_sc_hd__decap_3
X_5171_ _5171_/A _5200_/B VGND VGND VPWR VPWR _7242_/D sky130_fd_sc_hd__and2_2
XFILLER_69_724 VGND VGND VPWR VPWR sky130_fd_sc_hd__decap_3
XFILLER_123_681 VGND VGND VPWR VPWR sky130_fd_sc_hd__decap_3
XFILLER_68_212 VGND VGND VPWR VPWR sky130_fd_sc_hd__decap_3
X_4122_ _7204_/Q _3966_/S _4429_/A2 _7049_/Q _4121_/X VGND VGND VPWR VPWR _4122_/X
+ sky130_fd_sc_hd__a221o_2
XFILLER_110_320 VGND VGND VPWR VPWR sky130_fd_sc_hd__decap_3
XFILLER_96_554 VGND VGND VPWR VPWR sky130_fd_sc_hd__decap_3
XFILLER_84_716 VGND VGND VPWR VPWR sky130_fd_sc_hd__decap_3
XFILLER_110_353 VGND VGND VPWR VPWR sky130_fd_sc_hd__decap_3
XFILLER_96_587 VGND VGND VPWR VPWR sky130_fd_sc_hd__fill_1
XFILLER_83_204 VGND VGND VPWR VPWR sky130_fd_sc_hd__decap_3
X_4053_ _4054_/A _4456_/A VGND VGND VPWR VPWR _4055_/A sky130_fd_sc_hd__nor2_2
XFILLER_96_598 VGND VGND VPWR VPWR sky130_fd_sc_hd__decap_3
XFILLER_68_289 VGND VGND VPWR VPWR sky130_fd_sc_hd__decap_3
XFILLER_49_470 VGND VGND VPWR VPWR sky130_fd_sc_hd__decap_3
XFILLER_83_237 VGND VGND VPWR VPWR sky130_fd_sc_hd__decap_3
XFILLER_37_632 VGND VGND VPWR VPWR sky130_fd_sc_hd__decap_3
XFILLER_37_665 VGND VGND VPWR VPWR sky130_fd_sc_hd__decap_3
XFILLER_64_462 VGND VGND VPWR VPWR sky130_fd_sc_hd__fill_2
XFILLER_37_676 VGND VGND VPWR VPWR sky130_fd_sc_hd__decap_3
XFILLER_52_613 VGND VGND VPWR VPWR sky130_fd_sc_hd__decap_3
XFILLER_24_304 VGND VGND VPWR VPWR sky130_fd_sc_hd__decap_3
XTAP_TAPCELL_ROW_65_1116 VGND VPWR sky130_fd_sc_hd__tapvpwrvgnd_1
XFILLER_24_315 VGND VGND VPWR VPWR sky130_fd_sc_hd__decap_3
XFILLER_91_281 VGND VGND VPWR VPWR sky130_fd_sc_hd__decap_3
XFILLER_64_495 VGND VGND VPWR VPWR sky130_fd_sc_hd__decap_3
XFILLER_36_197 VGND VGND VPWR VPWR sky130_fd_sc_hd__decap_3
XFILLER_52_657 VGND VGND VPWR VPWR sky130_fd_sc_hd__decap_3
XFILLER_24_348 VGND VGND VPWR VPWR sky130_fd_sc_hd__decap_3
XPHY_EDGE_ROW_27_Right_27 VGND VGND VPWR VPWR sky130_fd_sc_hd__decap_3
X_4955_ _4970_/A1 _4639_/A _4200_/A _5033_/B2 VGND VGND VPWR VPWR _4955_/X sky130_fd_sc_hd__a22o_2
X_3906_ _6917_/Q _3906_/A2 _5660_/B _6691_/Q VGND VGND VPWR VPWR _3906_/X sky130_fd_sc_hd__a22o_2
X_4886_ _4886_/A _4890_/B _4886_/C VGND VGND VPWR VPWR _4886_/X sky130_fd_sc_hd__or3_2
XFILLER_60_690 VGND VGND VPWR VPWR sky130_fd_sc_hd__decap_3
XTAP_TAPCELL_ROW_22_549 VGND VPWR sky130_fd_sc_hd__tapvpwrvgnd_1
X_6625_ _6626_/A VGND VGND VPWR VPWR _6625_/Y sky130_fd_sc_hd__inv_2
X_3837_ _6755_/Q _3893_/B1 _3850_/B1 _6767_/Q VGND VGND VPWR VPWR _3837_/X sky130_fd_sc_hd__a22o_2
XFILLER_20_587 VGND VGND VPWR VPWR sky130_fd_sc_hd__fill_1
X_6556_ _6556_/A VGND VGND VPWR VPWR _6556_/Y sky130_fd_sc_hd__inv_2
XFILLER_20_598 VGND VGND VPWR VPWR sky130_fd_sc_hd__decap_3
X_3768_ _6931_/Q _3906_/A2 _3898_/B1 _6795_/Q VGND VGND VPWR VPWR _3768_/X sky130_fd_sc_hd__a22o_2
XFILLER_118_442 VGND VGND VPWR VPWR sky130_fd_sc_hd__fill_2
XFILLER_118_453 VGND VGND VPWR VPWR sky130_fd_sc_hd__decap_3
XFILLER_117_9 VGND VGND VPWR VPWR sky130_fd_sc_hd__decap_3
XFILLER_106_604 VGND VGND VPWR VPWR sky130_fd_sc_hd__decap_3
XFILLER_118_464 VGND VGND VPWR VPWR sky130_fd_sc_hd__decap_3
X_6487_ _6651_/A VGND VGND VPWR VPWR _6487_/Y sky130_fd_sc_hd__inv_2
XFILLER_118_486 VGND VGND VPWR VPWR sky130_fd_sc_hd__decap_3
X_3699_ _6713_/Q _3767_/A2 _3759_/B1 _6891_/Q VGND VGND VPWR VPWR _3699_/X sky130_fd_sc_hd__a22o_2
XFILLER_10_24 VGND VGND VPWR VPWR sky130_fd_sc_hd__decap_3
XFILLER_106_637 VGND VGND VPWR VPWR sky130_fd_sc_hd__decap_3
XTAP_TAPCELL_ROW_76_1256 VGND VPWR sky130_fd_sc_hd__tapvpwrvgnd_1
XFILLER_106_648 VGND VGND VPWR VPWR sky130_fd_sc_hd__decap_3
XPHY_EDGE_ROW_36_Right_36 VGND VGND VPWR VPWR sky130_fd_sc_hd__decap_3
XFILLER_105_169 VGND VGND VPWR VPWR sky130_fd_sc_hd__decap_3
XFILLER_121_629 VGND VGND VPWR VPWR sky130_fd_sc_hd__decap_3
XFILLER_120_106 VGND VGND VPWR VPWR sky130_fd_sc_hd__decap_3
X_5369_ _5369_/A0 _4752_/X _5383_/S VGND VGND VPWR VPWR _7148_/D sky130_fd_sc_hd__mux2_2
XFILLER_114_681 VGND VGND VPWR VPWR sky130_fd_sc_hd__decap_3
XFILLER_120_139 VGND VGND VPWR VPWR sky130_fd_sc_hd__fill_1
X_7108_ _7359_/CLK _7108_/D _6388_/Y VGND VGND VPWR VPWR _7108_/Q sky130_fd_sc_hd__dfrtp_2
XFILLER_59_234 VGND VGND VPWR VPWR sky130_fd_sc_hd__decap_3
XFILLER_101_320 VGND VGND VPWR VPWR sky130_fd_sc_hd__decap_3
XFILLER_87_554 VGND VGND VPWR VPWR sky130_fd_sc_hd__decap_3
XFILLER_87_576 VGND VGND VPWR VPWR sky130_fd_sc_hd__decap_3
XFILLER_75_727 VGND VGND VPWR VPWR sky130_fd_sc_hd__fill_1
XFILLER_19_109 VGND VGND VPWR VPWR sky130_fd_sc_hd__decap_3
X_7039_ _7386_/CLK _7039_/D _6319_/Y VGND VGND VPWR VPWR _7039_/Q sky130_fd_sc_hd__dfrtp_2
XFILLER_28_610 VGND VGND VPWR VPWR sky130_fd_sc_hd__decap_3
XFILLER_28_643 VGND VGND VPWR VPWR sky130_fd_sc_hd__fill_1
XFILLER_90_719 VGND VGND VPWR VPWR sky130_fd_sc_hd__decap_3
XFILLER_28_654 VGND VGND VPWR VPWR sky130_fd_sc_hd__decap_3
XFILLER_43_602 VGND VGND VPWR VPWR sky130_fd_sc_hd__decap_3
XFILLER_28_687 VGND VGND VPWR VPWR sky130_fd_sc_hd__decap_3
XTAP_TAPCELL_ROW_2_296 VGND VPWR sky130_fd_sc_hd__tapvpwrvgnd_1
XFILLER_42_101 VGND VGND VPWR VPWR sky130_fd_sc_hd__decap_3
XFILLER_15_315 VGND VGND VPWR VPWR sky130_fd_sc_hd__decap_3
XPHY_EDGE_ROW_45_Right_45 VGND VGND VPWR VPWR sky130_fd_sc_hd__decap_3
XTAP_TAPCELL_ROW_87_1396 VGND VPWR sky130_fd_sc_hd__tapvpwrvgnd_1
XFILLER_55_495 VGND VGND VPWR VPWR sky130_fd_sc_hd__decap_3
XFILLER_43_635 VGND VGND VPWR VPWR sky130_fd_sc_hd__decap_3
XFILLER_35_54 VGND VGND VPWR VPWR sky130_fd_sc_hd__fill_2
XFILLER_15_337 VGND VGND VPWR VPWR sky130_fd_sc_hd__decap_3
XFILLER_43_668 VGND VGND VPWR VPWR sky130_fd_sc_hd__decap_3
XFILLER_43_679 VGND VGND VPWR VPWR sky130_fd_sc_hd__decap_3
XTAP_TAPCELL_ROW_41_803 VGND VPWR sky130_fd_sc_hd__tapvpwrvgnd_1
XFILLER_23_381 VGND VGND VPWR VPWR sky130_fd_sc_hd__decap_3
XFILLER_11_576 VGND VGND VPWR VPWR sky130_fd_sc_hd__decap_3
XFILLER_109_420 VGND VGND VPWR VPWR sky130_fd_sc_hd__decap_3
XPHY_EDGE_ROW_54_Right_54 VGND VGND VPWR VPWR sky130_fd_sc_hd__decap_3
XPHY_EDGE_ROW_76_Left_200 VGND VGND VPWR VPWR sky130_fd_sc_hd__decap_3
XFILLER_109_497 VGND VGND VPWR VPWR sky130_fd_sc_hd__fill_1
XFILLER_112_607 VGND VGND VPWR VPWR sky130_fd_sc_hd__decap_3
XFILLER_78_510 VGND VGND VPWR VPWR sky130_fd_sc_hd__decap_3
XFILLER_120_640 VGND VGND VPWR VPWR sky130_fd_sc_hd__decap_3
XFILLER_120_651 VGND VGND VPWR VPWR sky130_fd_sc_hd__decap_3
XTAP_TAPCELL_ROW_49_903 VGND VPWR sky130_fd_sc_hd__tapvpwrvgnd_1
XFILLER_66_716 VGND VGND VPWR VPWR sky130_fd_sc_hd__decap_3
XFILLER_38_418 VGND VGND VPWR VPWR sky130_fd_sc_hd__fill_2
XFILLER_120_684 VGND VGND VPWR VPWR sky130_fd_sc_hd__decap_3
XFILLER_78_598 VGND VGND VPWR VPWR sky130_fd_sc_hd__decap_3
XFILLER_76_94 VGND VGND VPWR VPWR sky130_fd_sc_hd__fill_2
XFILLER_19_632 VGND VGND VPWR VPWR sky130_fd_sc_hd__decap_3
XPHY_EDGE_ROW_63_Right_63 VGND VGND VPWR VPWR sky130_fd_sc_hd__decap_3
XFILLER_93_579 VGND VGND VPWR VPWR sky130_fd_sc_hd__decap_3
XFILLER_19_665 VGND VGND VPWR VPWR sky130_fd_sc_hd__decap_3
XFILLER_19_676 VGND VGND VPWR VPWR sky130_fd_sc_hd__decap_3
XFILLER_46_473 VGND VGND VPWR VPWR sky130_fd_sc_hd__decap_3
XFILLER_34_613 VGND VGND VPWR VPWR sky130_fd_sc_hd__decap_3
XFILLER_73_270 VGND VGND VPWR VPWR sky130_fd_sc_hd__decap_3
XFILLER_73_281 VGND VGND VPWR VPWR sky130_fd_sc_hd__decap_3
XFILLER_61_421 VGND VGND VPWR VPWR sky130_fd_sc_hd__decap_3
XFILLER_18_197 VGND VGND VPWR VPWR sky130_fd_sc_hd__decap_3
XFILLER_34_657 VGND VGND VPWR VPWR sky130_fd_sc_hd__decap_3
XFILLER_92_82 VGND VGND VPWR VPWR sky130_fd_sc_hd__fill_2
XFILLER_61_476 VGND VGND VPWR VPWR sky130_fd_sc_hd__decap_3
XFILLER_33_178 VGND VGND VPWR VPWR sky130_fd_sc_hd__decap_3
X_4740_ _4745_/A _4765_/B _4611_/Y _4762_/A _4829_/A VGND VGND VPWR VPWR _4740_/X
+ sky130_fd_sc_hd__a221o_2
XFILLER_61_498 VGND VGND VPWR VPWR sky130_fd_sc_hd__decap_3
XFILLER_42_690 VGND VGND VPWR VPWR sky130_fd_sc_hd__decap_3
XFILLER_14_392 VGND VGND VPWR VPWR sky130_fd_sc_hd__decap_3
XTAP_TAPCELL_ROW_60_1046 VGND VPWR sky130_fd_sc_hd__tapvpwrvgnd_1
XFILLER_119_206 VGND VGND VPWR VPWR sky130_fd_sc_hd__fill_1
X_4671_ _6991_/Q _4671_/B VGND VGND VPWR VPWR _4982_/B sky130_fd_sc_hd__and2_2
X_6410_ _6640_/A VGND VGND VPWR VPWR _6410_/Y sky130_fd_sc_hd__inv_2
XFILLER_119_239 VGND VGND VPWR VPWR sky130_fd_sc_hd__decap_3
X_3622_ _4852_/A _5057_/A VGND VGND VPWR VPWR _3635_/B sky130_fd_sc_hd__nand2_2
X_7390_ _7401_/CLK _7390_/D _6670_/Y VGND VGND VPWR VPWR _7390_/Q sky130_fd_sc_hd__dfrtp_2
XPHY_EDGE_ROW_72_Right_72 VGND VGND VPWR VPWR sky130_fd_sc_hd__decap_3
X_6341_ _6630_/A VGND VGND VPWR VPWR _6341_/Y sky130_fd_sc_hd__inv_2
X_3553_ _3469_/A _3469_/B _3449_/A _7253_/Q _6980_/Q VGND VGND VPWR VPWR _3553_/X
+ sky130_fd_sc_hd__o2111a_2
XFILLER_115_412 VGND VGND VPWR VPWR sky130_fd_sc_hd__decap_3
XFILLER_115_445 VGND VGND VPWR VPWR sky130_fd_sc_hd__decap_3
X_6272_ _6649_/A VGND VGND VPWR VPWR _6272_/Y sky130_fd_sc_hd__inv_2
X_3484_ _4394_/A _4337_/B _3482_/Y _5153_/B VGND VGND VPWR VPWR _3485_/C sky130_fd_sc_hd__o31a_2
XFILLER_115_467 VGND VGND VPWR VPWR sky130_fd_sc_hd__decap_3
XFILLER_88_318 VGND VGND VPWR VPWR sky130_fd_sc_hd__decap_3
X_5223_ _5223_/A _5223_/B VGND VGND VPWR VPWR _7217_/D sky130_fd_sc_hd__and2_2
XFILLER_103_629 VGND VGND VPWR VPWR sky130_fd_sc_hd__decap_3
XFILLER_102_106 VGND VGND VPWR VPWR sky130_fd_sc_hd__decap_3
X_5154_ _5152_/Y _5153_/X _5647_/A VGND VGND VPWR VPWR _5154_/Y sky130_fd_sc_hd__a21oi_2
XFILLER_111_662 VGND VGND VPWR VPWR sky130_fd_sc_hd__decap_3
XTAP_TAPCELL_ROW_71_1186 VGND VPWR sky130_fd_sc_hd__tapvpwrvgnd_1
XFILLER_96_362 VGND VGND VPWR VPWR sky130_fd_sc_hd__fill_2
X_4105_ _7205_/Q _3943_/S _4419_/B1 _7397_/Q _4104_/X VGND VGND VPWR VPWR _4105_/X
+ sky130_fd_sc_hd__a221o_2
XFILLER_57_727 VGND VGND VPWR VPWR sky130_fd_sc_hd__fill_1
XFILLER_111_673 VGND VGND VPWR VPWR sky130_fd_sc_hd__decap_3
XFILLER_110_150 VGND VGND VPWR VPWR sky130_fd_sc_hd__decap_3
XFILLER_56_215 VGND VGND VPWR VPWR sky130_fd_sc_hd__decap_3
X_5085_ _5086_/A _5084_/B _5084_/X VGND VGND VPWR VPWR _5085_/X sky130_fd_sc_hd__o21ba_2
XPHY_EDGE_ROW_81_Right_81 VGND VGND VPWR VPWR sky130_fd_sc_hd__decap_3
XFILLER_56_248 VGND VGND VPWR VPWR sky130_fd_sc_hd__decap_3
X_4036_ _7310_/Q _4837_/S _4434_/A2 _7118_/Q _4035_/X VGND VGND VPWR VPWR _4036_/X
+ sky130_fd_sc_hd__a221o_2
XFILLER_56_259 VGND VGND VPWR VPWR sky130_fd_sc_hd__decap_3
XFILLER_72_719 VGND VGND VPWR VPWR sky130_fd_sc_hd__decap_3
XTAP_TAPCELL_ROW_27_619 VGND VPWR sky130_fd_sc_hd__tapvpwrvgnd_1
XFILLER_71_207 VGND VGND VPWR VPWR sky130_fd_sc_hd__decap_3
XFILLER_112_26 VGND VGND VPWR VPWR sky130_fd_sc_hd__fill_2
XFILLER_112_59 VGND VGND VPWR VPWR sky130_fd_sc_hd__decap_3
XFILLER_52_421 VGND VGND VPWR VPWR sky130_fd_sc_hd__decap_3
XFILLER_25_635 VGND VGND VPWR VPWR sky130_fd_sc_hd__decap_3
XFILLER_52_443 VGND VGND VPWR VPWR sky130_fd_sc_hd__decap_3
XFILLER_25_668 VGND VGND VPWR VPWR sky130_fd_sc_hd__decap_3
XFILLER_25_679 VGND VGND VPWR VPWR sky130_fd_sc_hd__decap_3
XFILLER_24_156 VGND VGND VPWR VPWR sky130_fd_sc_hd__decap_3
XFILLER_40_616 VGND VGND VPWR VPWR sky130_fd_sc_hd__decap_3
XFILLER_12_307 VGND VGND VPWR VPWR sky130_fd_sc_hd__fill_1
XFILLER_24_189 VGND VGND VPWR VPWR sky130_fd_sc_hd__decap_3
X_4938_ _4938_/A _4938_/B VGND VGND VPWR VPWR _4938_/Y sky130_fd_sc_hd__nor2_2
X_4869_ _6999_/Q _4858_/B _5015_/A VGND VGND VPWR VPWR _4870_/B sky130_fd_sc_hd__o21ai_2
XPHY_EDGE_ROW_90_Right_90 VGND VGND VPWR VPWR sky130_fd_sc_hd__decap_3
X_6608_ _6608_/A VGND VGND VPWR VPWR _6608_/Y sky130_fd_sc_hd__inv_2
XFILLER_115_6 VGND VGND VPWR VPWR sky130_fd_sc_hd__fill_1
X_6539_ _6633_/A VGND VGND VPWR VPWR _6539_/Y sky130_fd_sc_hd__inv_2
XFILLER_4_528 VGND VGND VPWR VPWR sky130_fd_sc_hd__decap_3
XFILLER_4_539 VGND VGND VPWR VPWR sky130_fd_sc_hd__decap_3
XFILLER_79_318 VGND VGND VPWR VPWR sky130_fd_sc_hd__decap_3
XFILLER_0_701 VGND VGND VPWR VPWR sky130_fd_sc_hd__decap_3
XTAP_TAPCELL_ROW_7_355 VGND VPWR sky130_fd_sc_hd__tapvpwrvgnd_1
XFILLER_102_640 VGND VGND VPWR VPWR sky130_fd_sc_hd__decap_3
XFILLER_87_340 VGND VGND VPWR VPWR sky130_fd_sc_hd__fill_1
XFILLER_102_651 VGND VGND VPWR VPWR sky130_fd_sc_hd__decap_3
XFILLER_87_362 VGND VGND VPWR VPWR sky130_fd_sc_hd__decap_3
XFILLER_48_716 VGND VGND VPWR VPWR sky130_fd_sc_hd__decap_3
XFILLER_102_684 VGND VGND VPWR VPWR sky130_fd_sc_hd__decap_3
XTAP_TAPCELL_ROW_89_1425 VGND VPWR sky130_fd_sc_hd__tapvpwrvgnd_1
XFILLER_101_183 VGND VGND VPWR VPWR sky130_fd_sc_hd__decap_3
XFILLER_75_557 VGND VGND VPWR VPWR sky130_fd_sc_hd__decap_3
XFILLER_16_613 VGND VGND VPWR VPWR sky130_fd_sc_hd__decap_3
XFILLER_62_229 VGND VGND VPWR VPWR sky130_fd_sc_hd__decap_3
XFILLER_55_270 VGND VGND VPWR VPWR sky130_fd_sc_hd__decap_3
XFILLER_55_281 VGND VGND VPWR VPWR sky130_fd_sc_hd__decap_3
XFILLER_28_495 VGND VGND VPWR VPWR sky130_fd_sc_hd__decap_3
XFILLER_43_432 VGND VGND VPWR VPWR sky130_fd_sc_hd__decap_3
XFILLER_15_123 VGND VGND VPWR VPWR sky130_fd_sc_hd__decap_3
XFILLER_16_657 VGND VGND VPWR VPWR sky130_fd_sc_hd__decap_3
XFILLER_43_443 VGND VGND VPWR VPWR sky130_fd_sc_hd__decap_3
XTAP_TAPCELL_ROW_54_972 VGND VPWR sky130_fd_sc_hd__tapvpwrvgnd_1
XFILLER_15_178 VGND VGND VPWR VPWR sky130_fd_sc_hd__decap_3
XFILLER_70_284 VGND VGND VPWR VPWR sky130_fd_sc_hd__decap_3
XFILLER_43_498 VGND VGND VPWR VPWR sky130_fd_sc_hd__decap_3
XFILLER_31_638 VGND VGND VPWR VPWR sky130_fd_sc_hd__decap_3
XFILLER_15_189 VGND VGND VPWR VPWR sky130_fd_sc_hd__decap_3
XFILLER_30_126 VGND VGND VPWR VPWR sky130_fd_sc_hd__decap_3
XFILLER_24_690 VGND VGND VPWR VPWR sky130_fd_sc_hd__decap_3
XFILLER_62_85 VGND VGND VPWR VPWR sky130_fd_sc_hd__decap_3
XFILLER_11_340 VGND VGND VPWR VPWR sky130_fd_sc_hd__decap_3
XFILLER_7_14 VGND VGND VPWR VPWR sky130_fd_sc_hd__decap_3
XFILLER_7_311 VGND VGND VPWR VPWR sky130_fd_sc_hd__decap_3
XFILLER_11_362 VGND VGND VPWR VPWR sky130_fd_sc_hd__decap_3
XFILLER_11_373 VGND VGND VPWR VPWR sky130_fd_sc_hd__fill_2
XFILLER_116_209 VGND VGND VPWR VPWR sky130_fd_sc_hd__decap_3
XFILLER_109_250 VGND VGND VPWR VPWR sky130_fd_sc_hd__fill_1
XFILLER_7_388 VGND VGND VPWR VPWR sky130_fd_sc_hd__decap_3
XFILLER_7_399 VGND VGND VPWR VPWR sky130_fd_sc_hd__decap_3
XFILLER_98_616 VGND VGND VPWR VPWR sky130_fd_sc_hd__decap_3
XFILLER_3_550 VGND VGND VPWR VPWR sky130_fd_sc_hd__decap_3
XTAP_TAPCELL_ROW_111_1710 VGND VPWR sky130_fd_sc_hd__tapvpwrvgnd_1
XFILLER_3_561 VGND VGND VPWR VPWR sky130_fd_sc_hd__decap_3
XFILLER_3_594 VGND VGND VPWR VPWR sky130_fd_sc_hd__decap_3
XFILLER_112_448 VGND VGND VPWR VPWR sky130_fd_sc_hd__decap_3
XFILLER_78_340 VGND VGND VPWR VPWR sky130_fd_sc_hd__fill_2
XFILLER_87_82 VGND VGND VPWR VPWR sky130_fd_sc_hd__decap_3
XFILLER_39_727 VGND VGND VPWR VPWR sky130_fd_sc_hd__fill_1
XFILLER_66_524 VGND VGND VPWR VPWR sky130_fd_sc_hd__decap_3
XFILLER_38_215 VGND VGND VPWR VPWR sky130_fd_sc_hd__decap_3
XFILLER_93_321 VGND VGND VPWR VPWR sky130_fd_sc_hd__decap_3
XFILLER_120_492 VGND VGND VPWR VPWR sky130_fd_sc_hd__decap_3
XFILLER_38_259 VGND VGND VPWR VPWR sky130_fd_sc_hd__decap_3
XFILLER_54_719 VGND VGND VPWR VPWR sky130_fd_sc_hd__decap_3
XTAP_TAPCELL_ROW_109_1683 VGND VPWR sky130_fd_sc_hd__tapvpwrvgnd_1
X_6890_ _7403_/CLK _6890_/D VGND VGND VPWR VPWR _6890_/Q sky130_fd_sc_hd__dfxtp_2
XFILLER_34_421 VGND VGND VPWR VPWR sky130_fd_sc_hd__fill_1
XFILLER_46_292 VGND VGND VPWR VPWR sky130_fd_sc_hd__decap_3
XFILLER_34_454 VGND VGND VPWR VPWR sky130_fd_sc_hd__decap_3
XFILLER_61_240 VGND VGND VPWR VPWR sky130_fd_sc_hd__decap_3
XFILLER_22_616 VGND VGND VPWR VPWR sky130_fd_sc_hd__decap_3
XTAP_TAPCELL_ROW_122_1850 VGND VPWR sky130_fd_sc_hd__tapvpwrvgnd_1
XFILLER_61_262 VGND VGND VPWR VPWR sky130_fd_sc_hd__fill_2
XFILLER_61_284 VGND VGND VPWR VPWR sky130_fd_sc_hd__decap_3
X_4723_ _3536_/B _4720_/A _4721_/Y _4970_/A1 VGND VGND VPWR VPWR _4723_/X sky130_fd_sc_hd__a22o_2
XTAP_TAPCELL_ROW_32_677 VGND VPWR sky130_fd_sc_hd__tapvpwrvgnd_1
XFILLER_30_660 VGND VGND VPWR VPWR sky130_fd_sc_hd__decap_3
XTAP_TAPCELL_ROW_32_688 VGND VPWR sky130_fd_sc_hd__tapvpwrvgnd_1
X_4654_ _4646_/Y _4647_/X _4653_/Y _4788_/B VGND VGND VPWR VPWR _4762_/A sky130_fd_sc_hd__a211o_2
XFILLER_30_693 VGND VGND VPWR VPWR sky130_fd_sc_hd__decap_3
X_3605_ _3621_/A _3621_/B VGND VGND VPWR VPWR _3605_/Y sky130_fd_sc_hd__nor2b_2
XFILLER_116_710 VGND VGND VPWR VPWR sky130_fd_sc_hd__decap_3
X_7373_ _7406_/CLK _7373_/D _6653_/Y VGND VGND VPWR VPWR _7373_/Q sky130_fd_sc_hd__dfrtp_2
X_4585_ _4585_/A _4595_/B VGND VGND VPWR VPWR _7288_/D sky130_fd_sc_hd__and2_2
Xhold801 _6816_/Q VGND VGND VPWR VPWR _6816_/D sky130_fd_sc_hd__dlygate4sd3_1
Xhold812 _6845_/Q VGND VGND VPWR VPWR _6845_/D sky130_fd_sc_hd__dlygate4sd3_1
Xhold823 _6975_/Q VGND VGND VPWR VPWR _6975_/D sky130_fd_sc_hd__dlygate4sd3_1
X_6324_ _6642_/A VGND VGND VPWR VPWR _6324_/Y sky130_fd_sc_hd__inv_2
Xhold834 _6890_/Q VGND VGND VPWR VPWR _6890_/D sky130_fd_sc_hd__dlygate4sd3_1
X_3536_ _4614_/A _3536_/B VGND VGND VPWR VPWR _3536_/Y sky130_fd_sc_hd__nand2_2
XTAP_TAPCELL_ROW_73_1215 VGND VPWR sky130_fd_sc_hd__tapvpwrvgnd_1
Xmax_cap553 _4795_/A VGND VGND VPWR VPWR _4647_/C sky130_fd_sc_hd__buf_2
Xhold845 _7061_/Q VGND VGND VPWR VPWR _7061_/D sky130_fd_sc_hd__dlygate4sd3_1
Xhold856 _7106_/Q VGND VGND VPWR VPWR _7106_/D sky130_fd_sc_hd__dlygate4sd3_1
Xmax_cap575 _6667_/A VGND VGND VPWR VPWR _6664_/A sky130_fd_sc_hd__buf_2
Xhold867 _7089_/Q VGND VGND VPWR VPWR _7089_/D sky130_fd_sc_hd__dlygate4sd3_1
Xhold878 _7070_/Q VGND VGND VPWR VPWR _7070_/D sky130_fd_sc_hd__dlygate4sd3_1
XFILLER_107_37 VGND VGND VPWR VPWR sky130_fd_sc_hd__decap_3
Xhold889 _7096_/Q VGND VGND VPWR VPWR _7096_/D sky130_fd_sc_hd__dlygate4sd3_1
XFILLER_89_638 VGND VGND VPWR VPWR sky130_fd_sc_hd__decap_3
XFILLER_88_115 VGND VGND VPWR VPWR sky130_fd_sc_hd__decap_3
X_3467_ _7121_/Q _4351_/B1 _3409_/X _7153_/Q _3466_/X VGND VGND VPWR VPWR _3467_/X
+ sky130_fd_sc_hd__a221o_2
XFILLER_88_159 VGND VGND VPWR VPWR sky130_fd_sc_hd__decap_3
XFILLER_69_340 VGND VGND VPWR VPWR sky130_fd_sc_hd__decap_3
XTAP_TAPCELL_ROW_4_314 VGND VPWR sky130_fd_sc_hd__tapvpwrvgnd_1
X_3398_ _4244_/B VGND VGND VPWR VPWR _3398_/Y sky130_fd_sc_hd__inv_2
XFILLER_97_671 VGND VGND VPWR VPWR sky130_fd_sc_hd__fill_1
XTAP_TAPCELL_ROW_4_325 VGND VPWR sky130_fd_sc_hd__tapvpwrvgnd_1
XFILLER_97_682 VGND VGND VPWR VPWR sky130_fd_sc_hd__decap_3
XFILLER_69_384 VGND VGND VPWR VPWR sky130_fd_sc_hd__decap_3
XFILLER_111_470 VGND VGND VPWR VPWR sky130_fd_sc_hd__decap_3
XFILLER_96_170 VGND VGND VPWR VPWR sky130_fd_sc_hd__decap_3
XFILLER_123_14 VGND VGND VPWR VPWR sky130_fd_sc_hd__decap_3
XFILLER_96_192 VGND VGND VPWR VPWR sky130_fd_sc_hd__decap_3
X_5068_ _6985_/Q _6986_/Q _5068_/C VGND VGND VPWR VPWR _5069_/B sky130_fd_sc_hd__and3_2
XFILLER_72_527 VGND VGND VPWR VPWR sky130_fd_sc_hd__decap_3
X_4019_ _7278_/Q _4437_/A2 _4430_/A2 _7246_/Q _4018_/X VGND VGND VPWR VPWR _4019_/X
+ sky130_fd_sc_hd__a221o_2
XFILLER_37_281 VGND VGND VPWR VPWR sky130_fd_sc_hd__decap_3
XTAP_TAPCELL_ROW_84_1355 VGND VPWR sky130_fd_sc_hd__tapvpwrvgnd_1
XFILLER_52_251 VGND VGND VPWR VPWR sky130_fd_sc_hd__fill_1
XPHY_EDGE_ROW_0_Right_0 VGND VGND VPWR VPWR sky130_fd_sc_hd__decap_3
XFILLER_16_78 VGND VGND VPWR VPWR sky130_fd_sc_hd__decap_3
XFILLER_25_487 VGND VGND VPWR VPWR sky130_fd_sc_hd__decap_3
XFILLER_12_104 VGND VGND VPWR VPWR sky130_fd_sc_hd__decap_3
XFILLER_13_638 VGND VGND VPWR VPWR sky130_fd_sc_hd__decap_3
XTAP_TAPCELL_ROW_51_931 VGND VPWR sky130_fd_sc_hd__tapvpwrvgnd_1
XFILLER_52_295 VGND VGND VPWR VPWR sky130_fd_sc_hd__decap_3
XFILLER_9_609 VGND VGND VPWR VPWR sky130_fd_sc_hd__decap_3
XFILLER_40_468 VGND VGND VPWR VPWR sky130_fd_sc_hd__decap_3
XFILLER_12_159 VGND VGND VPWR VPWR sky130_fd_sc_hd__decap_3
XFILLER_8_119 VGND VGND VPWR VPWR sky130_fd_sc_hd__decap_3
XFILLER_21_671 VGND VGND VPWR VPWR sky130_fd_sc_hd__fill_1
XFILLER_21_682 VGND VGND VPWR VPWR sky130_fd_sc_hd__decap_3
XFILLER_20_181 VGND VGND VPWR VPWR sky130_fd_sc_hd__decap_3
XFILLER_20_192 VGND VGND VPWR VPWR sky130_fd_sc_hd__decap_3
XFILLER_119_570 VGND VGND VPWR VPWR sky130_fd_sc_hd__decap_3
XFILLER_113_3 VGND VGND VPWR VPWR sky130_fd_sc_hd__decap_3
XFILLER_107_721 VGND VGND VPWR VPWR sky130_fd_sc_hd__decap_3
XFILLER_107_732 VGND VGND VPWR VPWR sky130_fd_sc_hd__decap_3
XFILLER_4_336 VGND VGND VPWR VPWR sky130_fd_sc_hd__decap_3
XFILLER_106_253 VGND VGND VPWR VPWR sky130_fd_sc_hd__decap_3
XFILLER_122_713 VGND VGND VPWR VPWR sky130_fd_sc_hd__decap_3
XFILLER_79_104 VGND VGND VPWR VPWR sky130_fd_sc_hd__decap_3
XFILLER_106_286 VGND VGND VPWR VPWR sky130_fd_sc_hd__decap_3
XFILLER_79_137 VGND VGND VPWR VPWR sky130_fd_sc_hd__decap_3
XFILLER_121_223 VGND VGND VPWR VPWR sky130_fd_sc_hd__fill_1
XFILLER_0_542 VGND VGND VPWR VPWR sky130_fd_sc_hd__decap_3
XFILLER_88_660 VGND VGND VPWR VPWR sky130_fd_sc_hd__decap_3
XFILLER_0_564 VGND VGND VPWR VPWR sky130_fd_sc_hd__decap_3
XFILLER_94_118 VGND VGND VPWR VPWR sky130_fd_sc_hd__decap_3
XFILLER_48_513 VGND VGND VPWR VPWR sky130_fd_sc_hd__fill_2
XFILLER_121_289 VGND VGND VPWR VPWR sky130_fd_sc_hd__decap_3
XFILLER_102_470 VGND VGND VPWR VPWR sky130_fd_sc_hd__decap_3
XFILLER_88_693 VGND VGND VPWR VPWR sky130_fd_sc_hd__decap_3
XFILLER_87_181 VGND VGND VPWR VPWR sky130_fd_sc_hd__fill_2
XFILLER_36_719 VGND VGND VPWR VPWR sky130_fd_sc_hd__decap_3
XFILLER_63_505 VGND VGND VPWR VPWR sky130_fd_sc_hd__decap_3
XFILLER_35_207 VGND VGND VPWR VPWR sky130_fd_sc_hd__decap_3
XFILLER_16_421 VGND VGND VPWR VPWR sky130_fd_sc_hd__decap_3
XPHY_EDGE_ROW_121_Right_121 VGND VGND VPWR VPWR sky130_fd_sc_hd__decap_3
XFILLER_28_292 VGND VGND VPWR VPWR sky130_fd_sc_hd__decap_3
XFILLER_90_368 VGND VGND VPWR VPWR sky130_fd_sc_hd__decap_3
XFILLER_43_240 VGND VGND VPWR VPWR sky130_fd_sc_hd__decap_3
XFILLER_16_465 VGND VGND VPWR VPWR sky130_fd_sc_hd__decap_3
XFILLER_16_487 VGND VGND VPWR VPWR sky130_fd_sc_hd__decap_3
XFILLER_73_95 VGND VGND VPWR VPWR sky130_fd_sc_hd__decap_3
XFILLER_43_284 VGND VGND VPWR VPWR sky130_fd_sc_hd__decap_3
XFILLER_31_424 VGND VGND VPWR VPWR sky130_fd_sc_hd__decap_3
XFILLER_31_479 VGND VGND VPWR VPWR sky130_fd_sc_hd__decap_3
XFILLER_12_660 VGND VGND VPWR VPWR sky130_fd_sc_hd__decap_3
XFILLER_8_631 VGND VGND VPWR VPWR sky130_fd_sc_hd__decap_3
XFILLER_78_6 VGND VGND VPWR VPWR sky130_fd_sc_hd__decap_3
XFILLER_12_693 VGND VGND VPWR VPWR sky130_fd_sc_hd__decap_3
XFILLER_11_192 VGND VGND VPWR VPWR sky130_fd_sc_hd__fill_1
XFILLER_8_675 VGND VGND VPWR VPWR sky130_fd_sc_hd__decap_3
XFILLER_117_529 VGND VGND VPWR VPWR sky130_fd_sc_hd__decap_3
X_4370_ _5100_/B _4361_/X _4362_/X _4369_/Y VGND VGND VPWR VPWR _5032_/B sky130_fd_sc_hd__a211o_2
X_3321_ _6981_/Q _3327_/B VGND VGND VPWR VPWR _5294_/A sky130_fd_sc_hd__or2_4
XFILLER_113_724 VGND VGND VPWR VPWR sky130_fd_sc_hd__decap_3
XFILLER_98_424 VGND VGND VPWR VPWR sky130_fd_sc_hd__decap_3
XFILLER_98_457 VGND VGND VPWR VPWR sky130_fd_sc_hd__decap_3
XFILLER_3_391 VGND VGND VPWR VPWR sky130_fd_sc_hd__fill_1
XFILLER_112_245 VGND VGND VPWR VPWR sky130_fd_sc_hd__decap_3
XFILLER_86_619 VGND VGND VPWR VPWR sky130_fd_sc_hd__decap_3
XPHY_EDGE_ROW_13_Left_137 VGND VGND VPWR VPWR sky130_fd_sc_hd__decap_3
XFILLER_79_671 VGND VGND VPWR VPWR sky130_fd_sc_hd__fill_1
XFILLER_79_682 VGND VGND VPWR VPWR sky130_fd_sc_hd__decap_3
XFILLER_66_321 VGND VGND VPWR VPWR sky130_fd_sc_hd__decap_3
XFILLER_66_343 VGND VGND VPWR VPWR sky130_fd_sc_hd__decap_3
XFILLER_94_663 VGND VGND VPWR VPWR sky130_fd_sc_hd__decap_3
XFILLER_66_365 VGND VGND VPWR VPWR sky130_fd_sc_hd__decap_3
XFILLER_94_696 VGND VGND VPWR VPWR sky130_fd_sc_hd__decap_3
XFILLER_81_313 VGND VGND VPWR VPWR sky130_fd_sc_hd__decap_3
XFILLER_93_184 VGND VGND VPWR VPWR sky130_fd_sc_hd__decap_3
XFILLER_26_229 VGND VGND VPWR VPWR sky130_fd_sc_hd__decap_3
X_6942_ _6942_/CLK _6942_/D VGND VGND VPWR VPWR _6942_/Q sky130_fd_sc_hd__dfxtp_2
XTAP_TAPCELL_ROW_37_747 VGND VPWR sky130_fd_sc_hd__tapvpwrvgnd_1
XFILLER_19_292 VGND VGND VPWR VPWR sky130_fd_sc_hd__decap_3
X_6873_ clkload8/A _6873_/D VGND VGND VPWR VPWR _6873_/Q sky130_fd_sc_hd__dfxtp_2
XFILLER_62_560 VGND VGND VPWR VPWR sky130_fd_sc_hd__decap_3
XFILLER_34_262 VGND VGND VPWR VPWR sky130_fd_sc_hd__decap_3
XFILLER_50_722 VGND VGND VPWR VPWR sky130_fd_sc_hd__decap_3
XFILLER_22_424 VGND VGND VPWR VPWR sky130_fd_sc_hd__decap_3
XTAP_TAPCELL_ROW_17_482 VGND VPWR sky130_fd_sc_hd__tapvpwrvgnd_1
XPHY_EDGE_ROW_22_Left_146 VGND VGND VPWR VPWR sky130_fd_sc_hd__decap_3
XTAP_TAPCELL_ROW_17_493 VGND VPWR sky130_fd_sc_hd__tapvpwrvgnd_1
XFILLER_22_446 VGND VGND VPWR VPWR sky130_fd_sc_hd__decap_3
XFILLER_10_619 VGND VGND VPWR VPWR sky130_fd_sc_hd__decap_3
X_4706_ _6997_/Q _4931_/A VGND VGND VPWR VPWR _4912_/A sky130_fd_sc_hd__and2_2
X_5686_ _7349_/Q hold919/X _5712_/S VGND VGND VPWR VPWR _6693_/D sky130_fd_sc_hd__mux2_2
XFILLER_108_507 VGND VGND VPWR VPWR sky130_fd_sc_hd__decap_3
XFILLER_108_529 VGND VGND VPWR VPWR sky130_fd_sc_hd__decap_3
X_4637_ _4380_/B _4637_/B _4637_/C VGND VGND VPWR VPWR _4950_/B sky130_fd_sc_hd__and3b_2
XFILLER_118_47 VGND VGND VPWR VPWR sky130_fd_sc_hd__decap_3
Xhold620 _6750_/Q VGND VGND VPWR VPWR _6750_/D sky130_fd_sc_hd__dlygate4sd3_1
Xhold631 _6766_/Q VGND VGND VPWR VPWR _6766_/D sky130_fd_sc_hd__dlygate4sd3_1
X_7356_ _7356_/CLK _7356_/D _6636_/Y VGND VGND VPWR VPWR _7356_/Q sky130_fd_sc_hd__dfrtp_2
XFILLER_116_551 VGND VGND VPWR VPWR sky130_fd_sc_hd__decap_3
Xhold642 _6924_/Q VGND VGND VPWR VPWR _6924_/D sky130_fd_sc_hd__dlygate4sd3_1
XFILLER_78_18 VGND VGND VPWR VPWR sky130_fd_sc_hd__fill_2
Xhold653 _6931_/Q VGND VGND VPWR VPWR _6931_/D sky130_fd_sc_hd__dlygate4sd3_1
XFILLER_78_29 VGND VGND VPWR VPWR sky130_fd_sc_hd__decap_3
XFILLER_104_713 VGND VGND VPWR VPWR sky130_fd_sc_hd__decap_3
X_3519_ _5129_/B _3519_/B VGND VGND VPWR VPWR _3519_/Y sky130_fd_sc_hd__nor2_2
X_6307_ _6557_/A VGND VGND VPWR VPWR _6307_/Y sky130_fd_sc_hd__inv_2
Xhold664 _6852_/Q VGND VGND VPWR VPWR _6852_/D sky130_fd_sc_hd__dlygate4sd3_1
XFILLER_116_584 VGND VGND VPWR VPWR sky130_fd_sc_hd__decap_3
Xhold675 _6908_/Q VGND VGND VPWR VPWR _6908_/D sky130_fd_sc_hd__dlygate4sd3_1
X_7287_ _7354_/CLK _7287_/D _6567_/Y VGND VGND VPWR VPWR _7287_/Q sky130_fd_sc_hd__dfrtp_2
XFILLER_116_595 VGND VGND VPWR VPWR sky130_fd_sc_hd__decap_3
XFILLER_103_212 VGND VGND VPWR VPWR sky130_fd_sc_hd__fill_1
XPHY_EDGE_ROW_31_Left_155 VGND VGND VPWR VPWR sky130_fd_sc_hd__decap_3
X_4499_ _4499_/A0 _7298_/Q _4505_/S VGND VGND VPWR VPWR _7330_/D sky130_fd_sc_hd__mux2_2
Xhold686 _6966_/Q VGND VGND VPWR VPWR _6966_/D sky130_fd_sc_hd__dlygate4sd3_1
Xhold697 _6840_/Q VGND VGND VPWR VPWR _6840_/D sky130_fd_sc_hd__dlygate4sd3_1
XFILLER_89_479 VGND VGND VPWR VPWR sky130_fd_sc_hd__decap_3
XFILLER_103_289 VGND VGND VPWR VPWR sky130_fd_sc_hd__decap_3
XFILLER_69_181 VGND VGND VPWR VPWR sky130_fd_sc_hd__decap_3
XFILLER_85_641 VGND VGND VPWR VPWR sky130_fd_sc_hd__decap_3
XFILLER_45_505 VGND VGND VPWR VPWR sky130_fd_sc_hd__fill_1
XFILLER_18_719 VGND VGND VPWR VPWR sky130_fd_sc_hd__decap_3
XFILLER_85_685 VGND VGND VPWR VPWR sky130_fd_sc_hd__decap_3
XFILLER_17_218 VGND VGND VPWR VPWR sky130_fd_sc_hd__decap_3
XFILLER_27_66 VGND VGND VPWR VPWR sky130_fd_sc_hd__decap_3
XFILLER_84_195 VGND VGND VPWR VPWR sky130_fd_sc_hd__fill_1
XPHY_EDGE_ROW_40_Left_164 VGND VGND VPWR VPWR sky130_fd_sc_hd__decap_3
XFILLER_41_700 VGND VGND VPWR VPWR sky130_fd_sc_hd__decap_3
XFILLER_13_402 VGND VGND VPWR VPWR sky130_fd_sc_hd__decap_3
XFILLER_25_273 VGND VGND VPWR VPWR sky130_fd_sc_hd__decap_3
XFILLER_43_21 VGND VGND VPWR VPWR sky130_fd_sc_hd__fill_1
XFILLER_40_210 VGND VGND VPWR VPWR sky130_fd_sc_hd__decap_3
XFILLER_25_284 VGND VGND VPWR VPWR sky130_fd_sc_hd__decap_3
XFILLER_80_390 VGND VGND VPWR VPWR sky130_fd_sc_hd__fill_1
XFILLER_40_232 VGND VGND VPWR VPWR sky130_fd_sc_hd__decap_3
XTAP_TAPCELL_ROW_97_1524 VGND VPWR sky130_fd_sc_hd__tapvpwrvgnd_1
Xclkbuf_leaf_20_clk clkload3/A VGND VGND VPWR VPWR _7395_/CLK sky130_fd_sc_hd__clkbuf_16
XFILLER_5_612 VGND VGND VPWR VPWR sky130_fd_sc_hd__decap_3
XFILLER_5_623 VGND VGND VPWR VPWR sky130_fd_sc_hd__decap_3
XFILLER_5_656 VGND VGND VPWR VPWR sky130_fd_sc_hd__decap_3
XFILLER_107_573 VGND VGND VPWR VPWR sky130_fd_sc_hd__decap_3
XFILLER_122_510 VGND VGND VPWR VPWR sky130_fd_sc_hd__decap_3
XFILLER_122_554 VGND VGND VPWR VPWR sky130_fd_sc_hd__decap_3
XFILLER_95_405 VGND VGND VPWR VPWR sky130_fd_sc_hd__decap_3
XFILLER_68_619 VGND VGND VPWR VPWR sky130_fd_sc_hd__decap_3
XFILLER_110_716 VGND VGND VPWR VPWR sky130_fd_sc_hd__decap_3
XFILLER_122_587 VGND VGND VPWR VPWR sky130_fd_sc_hd__fill_1
XFILLER_95_438 VGND VGND VPWR VPWR sky130_fd_sc_hd__decap_3
XFILLER_122_598 VGND VGND VPWR VPWR sky130_fd_sc_hd__decap_3
XFILLER_95_449 VGND VGND VPWR VPWR sky130_fd_sc_hd__fill_2
XFILLER_88_490 VGND VGND VPWR VPWR sky130_fd_sc_hd__fill_2
XFILLER_76_663 VGND VGND VPWR VPWR sky130_fd_sc_hd__decap_3
XFILLER_48_354 VGND VGND VPWR VPWR sky130_fd_sc_hd__decap_3
XFILLER_91_600 VGND VGND VPWR VPWR sky130_fd_sc_hd__decap_3
XFILLER_48_365 VGND VGND VPWR VPWR sky130_fd_sc_hd__fill_1
XFILLER_75_162 VGND VGND VPWR VPWR sky130_fd_sc_hd__decap_3
XFILLER_63_302 VGND VGND VPWR VPWR sky130_fd_sc_hd__decap_3
XFILLER_76_696 VGND VGND VPWR VPWR sky130_fd_sc_hd__decap_3
Xplace302 _3651_/Y VGND VGND VPWR VPWR _3889_/A2 sky130_fd_sc_hd__buf_2
XFILLER_91_644 VGND VGND VPWR VPWR sky130_fd_sc_hd__decap_3
XFILLER_63_335 VGND VGND VPWR VPWR sky130_fd_sc_hd__fill_1
Xplace313 _3618_/X VGND VGND VPWR VPWR _4969_/B sky130_fd_sc_hd__buf_2
XFILLER_84_83 VGND VGND VPWR VPWR sky130_fd_sc_hd__fill_1
XFILLER_63_346 VGND VGND VPWR VPWR sky130_fd_sc_hd__decap_3
XTAP_TAPCELL_ROW_106_1642 VGND VPWR sky130_fd_sc_hd__tapvpwrvgnd_1
Xplace324 _4437_/A2 VGND VGND VPWR VPWR _4431_/A2 sky130_fd_sc_hd__buf_2
XTAP_TAPCELL_ROW_34_706 VGND VPWR sky130_fd_sc_hd__tapvpwrvgnd_1
Xplace335 _5688_/S VGND VGND VPWR VPWR _5708_/S sky130_fd_sc_hd__buf_2
Xplace346 _5092_/C VGND VGND VPWR VPWR _4910_/A sky130_fd_sc_hd__buf_2
XFILLER_91_688 VGND VGND VPWR VPWR sky130_fd_sc_hd__decap_3
Xplace357 _4914_/S VGND VGND VPWR VPWR _4837_/S sky130_fd_sc_hd__buf_2
Xplace368 _3558_/B VGND VGND VPWR VPWR _4305_/B sky130_fd_sc_hd__buf_2
XFILLER_16_262 VGND VGND VPWR VPWR sky130_fd_sc_hd__fill_2
XFILLER_32_722 VGND VGND VPWR VPWR sky130_fd_sc_hd__decap_3
Xplace379 _3339_/Y VGND VGND VPWR VPWR _3469_/A sky130_fd_sc_hd__buf_2
XFILLER_16_284 VGND VGND VPWR VPWR sky130_fd_sc_hd__decap_3
X_3870_ _6760_/Q _3913_/A2 _3917_/A2 _6754_/Q _3869_/X VGND VGND VPWR VPWR _3870_/X
+ sky130_fd_sc_hd__a221o_2
XFILLER_71_390 VGND VGND VPWR VPWR sky130_fd_sc_hd__fill_2
XFILLER_31_243 VGND VGND VPWR VPWR sky130_fd_sc_hd__decap_3
XTAP_TAPCELL_ROW_14_452 VGND VPWR sky130_fd_sc_hd__tapvpwrvgnd_1
XFILLER_31_287 VGND VGND VPWR VPWR sky130_fd_sc_hd__decap_3
Xclkbuf_leaf_11_clk clkbuf_leaf_9_clk/A VGND VGND VPWR VPWR _6942_/CLK sky130_fd_sc_hd__clkbuf_16
XFILLER_8_450 VGND VGND VPWR VPWR sky130_fd_sc_hd__decap_3
XFILLER_8_483 VGND VGND VPWR VPWR sky130_fd_sc_hd__fill_1
XFILLER_117_337 VGND VGND VPWR VPWR sky130_fd_sc_hd__decap_3
XTAP_TAPCELL_ROW_57_1007 VGND VPWR sky130_fd_sc_hd__tapvpwrvgnd_1
X_4422_ _7272_/Q _4422_/A2 _4419_/X _4421_/X VGND VGND VPWR VPWR _4422_/X sky130_fd_sc_hd__a211o_2
X_7210_ _7404_/CLK _7210_/D _6490_/Y VGND VGND VPWR VPWR _7210_/Q sky130_fd_sc_hd__dfrtp_2
XFILLER_99_700 VGND VGND VPWR VPWR sky130_fd_sc_hd__decap_3
XTAP_TAPCELL_ROW_117_1782 VGND VPWR sky130_fd_sc_hd__tapvpwrvgnd_1
XTAP_TAPCELL_ROW_117_1793 VGND VPWR sky130_fd_sc_hd__tapvpwrvgnd_1
X_7141_ _7395_/CLK _7141_/D _6421_/Y VGND VGND VPWR VPWR _7141_/Q sky130_fd_sc_hd__dfrtp_2
X_4353_ _7225_/Q _4353_/A2 _3964_/S _7193_/Q VGND VGND VPWR VPWR _4355_/A sky130_fd_sc_hd__a22o_2
XFILLER_98_221 VGND VGND VPWR VPWR sky130_fd_sc_hd__fill_1
XFILLER_113_532 VGND VGND VPWR VPWR sky130_fd_sc_hd__decap_3
X_3304_ _3340_/A _3327_/B VGND VGND VPWR VPWR _4696_/B sky130_fd_sc_hd__nand2_2
X_7072_ _7392_/CLK _7072_/D _6352_/Y VGND VGND VPWR VPWR _7072_/Q sky130_fd_sc_hd__dfrtp_2
X_4284_ _7222_/Q _4307_/A2 _3989_/S _7190_/Q VGND VGND VPWR VPWR _4286_/A sky130_fd_sc_hd__a22o_2
XFILLER_113_576 VGND VGND VPWR VPWR sky130_fd_sc_hd__decap_3
XFILLER_98_287 VGND VGND VPWR VPWR sky130_fd_sc_hd__decap_3
XFILLER_58_118 VGND VGND VPWR VPWR sky130_fd_sc_hd__decap_3
XFILLER_101_727 VGND VGND VPWR VPWR sky130_fd_sc_hd__fill_1
XFILLER_100_215 VGND VGND VPWR VPWR sky130_fd_sc_hd__decap_3
XFILLER_39_310 VGND VGND VPWR VPWR sky130_fd_sc_hd__fill_2
XFILLER_67_641 VGND VGND VPWR VPWR sky130_fd_sc_hd__decap_3
XFILLER_39_332 VGND VGND VPWR VPWR sky130_fd_sc_hd__decap_3
XFILLER_100_248 VGND VGND VPWR VPWR sky130_fd_sc_hd__decap_3
XFILLER_100_259 VGND VGND VPWR VPWR sky130_fd_sc_hd__decap_3
XFILLER_39_354 VGND VGND VPWR VPWR sky130_fd_sc_hd__decap_3
XFILLER_27_505 VGND VGND VPWR VPWR sky130_fd_sc_hd__decap_3
XFILLER_94_460 VGND VGND VPWR VPWR sky130_fd_sc_hd__decap_3
XFILLER_67_685 VGND VGND VPWR VPWR sky130_fd_sc_hd__decap_3
XFILLER_94_471 VGND VGND VPWR VPWR sky130_fd_sc_hd__decap_3
XFILLER_82_622 VGND VGND VPWR VPWR sky130_fd_sc_hd__decap_3
XFILLER_54_324 VGND VGND VPWR VPWR sky130_fd_sc_hd__decap_3
XTAP_TAPCELL_ROW_68_1147 VGND VPWR sky130_fd_sc_hd__tapvpwrvgnd_1
XFILLER_81_121 VGND VGND VPWR VPWR sky130_fd_sc_hd__decap_3
XFILLER_82_666 VGND VGND VPWR VPWR sky130_fd_sc_hd__decap_3
X_6925_ _7380_/CLK _6925_/D VGND VGND VPWR VPWR _6925_/Q sky130_fd_sc_hd__dfxtp_2
XFILLER_42_519 VGND VGND VPWR VPWR sky130_fd_sc_hd__decap_3
XFILLER_23_700 VGND VGND VPWR VPWR sky130_fd_sc_hd__decap_3
XFILLER_82_699 VGND VGND VPWR VPWR sky130_fd_sc_hd__fill_1
XFILLER_120_26 VGND VGND VPWR VPWR sky130_fd_sc_hd__fill_2
XTAP_TAPCELL_ROW_81_1314 VGND VPWR sky130_fd_sc_hd__tapvpwrvgnd_1
XTAP_TAPCELL_ROW_81_1325 VGND VPWR sky130_fd_sc_hd__tapvpwrvgnd_1
XFILLER_22_210 VGND VGND VPWR VPWR sky130_fd_sc_hd__decap_3
X_6856_ _6965_/CLK _6856_/D VGND VGND VPWR VPWR _6856_/Q sky130_fd_sc_hd__dfxtp_2
Xfanout25 _6626_/A VGND VGND VPWR VPWR _6591_/A sky130_fd_sc_hd__buf_2
XFILLER_120_59 VGND VGND VPWR VPWR sky130_fd_sc_hd__decap_3
Xfanout36 fanout47/X VGND VGND VPWR VPWR _6637_/A sky130_fd_sc_hd__clkdlybuf4s25_1
Xfanout47 reset VGND VGND VPWR VPWR fanout47/X sky130_fd_sc_hd__clkdlybuf4s25_1
Xfanout58 _6616_/A VGND VGND VPWR VPWR _6646_/A sky130_fd_sc_hd__clkdlybuf4s25_1
Xfanout69 _6553_/A VGND VGND VPWR VPWR _6557_/A sky130_fd_sc_hd__buf_1
XFILLER_50_574 VGND VGND VPWR VPWR sky130_fd_sc_hd__decap_3
X_6787_ _6965_/CLK _6787_/D VGND VGND VPWR VPWR _6787_/Q sky130_fd_sc_hd__dfxtp_2
XFILLER_50_585 VGND VGND VPWR VPWR sky130_fd_sc_hd__decap_3
XFILLER_10_416 VGND VGND VPWR VPWR sky130_fd_sc_hd__decap_3
XFILLER_13_57 VGND VGND VPWR VPWR sky130_fd_sc_hd__decap_3
XFILLER_6_409 VGND VGND VPWR VPWR sky130_fd_sc_hd__decap_3
XFILLER_108_304 VGND VGND VPWR VPWR sky130_fd_sc_hd__decap_3
XTAP_TAPCELL_ROW_79_1298 VGND VPWR sky130_fd_sc_hd__tapvpwrvgnd_1
XFILLER_2_626 VGND VGND VPWR VPWR sky130_fd_sc_hd__decap_3
XFILLER_123_329 VGND VGND VPWR VPWR sky130_fd_sc_hd__decap_3
XFILLER_89_210 VGND VGND VPWR VPWR sky130_fd_sc_hd__decap_3
X_7339_ _7371_/CLK _7339_/D _6619_/Y VGND VGND VPWR VPWR _7339_/Q sky130_fd_sc_hd__dfrtp_2
XFILLER_8_6 VGND VGND VPWR VPWR sky130_fd_sc_hd__fill_1
XFILLER_2_648 VGND VGND VPWR VPWR sky130_fd_sc_hd__decap_3
XTAP_TAPCELL_ROW_92_1465 VGND VPWR sky130_fd_sc_hd__tapvpwrvgnd_1
XFILLER_89_243 VGND VGND VPWR VPWR sky130_fd_sc_hd__decap_3
XFILLER_104_554 VGND VGND VPWR VPWR sky130_fd_sc_hd__decap_3
XFILLER_1_169 VGND VGND VPWR VPWR sky130_fd_sc_hd__decap_3
XFILLER_89_276 VGND VGND VPWR VPWR sky130_fd_sc_hd__decap_3
XFILLER_104_587 VGND VGND VPWR VPWR sky130_fd_sc_hd__fill_1
XFILLER_89_287 VGND VGND VPWR VPWR sky130_fd_sc_hd__decap_3
XFILLER_104_598 VGND VGND VPWR VPWR sky130_fd_sc_hd__decap_3
XFILLER_77_449 VGND VGND VPWR VPWR sky130_fd_sc_hd__decap_3
XFILLER_58_641 VGND VGND VPWR VPWR sky130_fd_sc_hd__decap_3
XFILLER_58_663 VGND VGND VPWR VPWR sky130_fd_sc_hd__decap_3
XFILLER_92_419 VGND VGND VPWR VPWR sky130_fd_sc_hd__fill_1
Xhold1150 _7280_/Q VGND VGND VPWR VPWR _4601_/A0 sky130_fd_sc_hd__dlygate4sd3_1
XFILLER_18_516 VGND VGND VPWR VPWR sky130_fd_sc_hd__fill_2
XFILLER_85_471 VGND VGND VPWR VPWR sky130_fd_sc_hd__decap_3
XFILLER_73_611 VGND VGND VPWR VPWR sky130_fd_sc_hd__decap_3
Xhold1161 _7136_/Q VGND VGND VPWR VPWR _5394_/A0 sky130_fd_sc_hd__dlygate4sd3_1
XFILLER_58_696 VGND VGND VPWR VPWR sky130_fd_sc_hd__decap_3
XFILLER_57_173 VGND VGND VPWR VPWR sky130_fd_sc_hd__decap_3
Xhold1172 _7167_/Q VGND VGND VPWR VPWR _5327_/A0 sky130_fd_sc_hd__dlygate4sd3_1
Xhold1183 _7147_/Q VGND VGND VPWR VPWR _5371_/A0 sky130_fd_sc_hd__dlygate4sd3_1
XFILLER_73_644 VGND VGND VPWR VPWR sky130_fd_sc_hd__decap_3
Xhold1194 _7015_/Q VGND VGND VPWR VPWR _5626_/A sky130_fd_sc_hd__dlygate4sd3_1
XFILLER_72_121 VGND VGND VPWR VPWR sky130_fd_sc_hd__decap_3
XFILLER_33_508 VGND VGND VPWR VPWR sky130_fd_sc_hd__decap_3
XFILLER_73_688 VGND VGND VPWR VPWR sky130_fd_sc_hd__decap_3
XFILLER_72_165 VGND VGND VPWR VPWR sky130_fd_sc_hd__decap_3
XFILLER_14_722 VGND VGND VPWR VPWR sky130_fd_sc_hd__decap_3
XFILLER_60_338 VGND VGND VPWR VPWR sky130_fd_sc_hd__decap_3
XFILLER_13_243 VGND VGND VPWR VPWR sky130_fd_sc_hd__decap_3
XFILLER_9_225 VGND VGND VPWR VPWR sky130_fd_sc_hd__fill_2
XFILLER_13_287 VGND VGND VPWR VPWR sky130_fd_sc_hd__decap_3
XTAP_TAPCELL_ROW_11_411 VGND VPWR sky130_fd_sc_hd__tapvpwrvgnd_1
XFILLER_70_41 VGND VGND VPWR VPWR sky130_fd_sc_hd__fill_1
XTAP_TAPCELL_ROW_101_1583 VGND VPWR sky130_fd_sc_hd__tapvpwrvgnd_1
XFILLER_9_269 VGND VGND VPWR VPWR sky130_fd_sc_hd__decap_3
XFILLER_70_63 VGND VGND VPWR VPWR sky130_fd_sc_hd__decap_3
Xclkload17 _7325_/CLK VGND VGND VPWR VPWR clkload17/X sky130_fd_sc_hd__clkbuf_8
Xclkload28 _7398_/CLK VGND VGND VPWR VPWR clkload28/Y sky130_fd_sc_hd__bufinv_16
XFILLER_5_442 VGND VGND VPWR VPWR sky130_fd_sc_hd__decap_3
XFILLER_119_90 VGND VGND VPWR VPWR sky130_fd_sc_hd__decap_3
XFILLER_114_329 VGND VGND VPWR VPWR sky130_fd_sc_hd__fill_2
XFILLER_79_72 VGND VGND VPWR VPWR sky130_fd_sc_hd__decap_3
XFILLER_96_725 VGND VGND VPWR VPWR sky130_fd_sc_hd__decap_3
XFILLER_68_427 VGND VGND VPWR VPWR sky130_fd_sc_hd__decap_3
XFILLER_110_524 VGND VGND VPWR VPWR sky130_fd_sc_hd__decap_3
XFILLER_0_180 VGND VGND VPWR VPWR sky130_fd_sc_hd__decap_3
XFILLER_49_641 VGND VGND VPWR VPWR sky130_fd_sc_hd__decap_3
XFILLER_110_557 VGND VGND VPWR VPWR sky130_fd_sc_hd__decap_3
Xclkbuf_leaf_0_clk clkbuf_leaf_1_clk/A VGND VGND VPWR VPWR clkload4/A sky130_fd_sc_hd__clkbuf_16
XFILLER_76_471 VGND VGND VPWR VPWR sky130_fd_sc_hd__decap_3
XFILLER_49_685 VGND VGND VPWR VPWR sky130_fd_sc_hd__decap_3
XFILLER_64_622 VGND VGND VPWR VPWR sky130_fd_sc_hd__decap_3
XTAP_TAPCELL_ROW_19_511 VGND VPWR sky130_fd_sc_hd__tapvpwrvgnd_1
XFILLER_36_324 VGND VGND VPWR VPWR sky130_fd_sc_hd__decap_3
XFILLER_91_441 VGND VGND VPWR VPWR sky130_fd_sc_hd__decap_3
XFILLER_63_132 VGND VGND VPWR VPWR sky130_fd_sc_hd__decap_3
XFILLER_64_666 VGND VGND VPWR VPWR sky130_fd_sc_hd__decap_3
XFILLER_91_452 VGND VGND VPWR VPWR sky130_fd_sc_hd__decap_3
XFILLER_36_368 VGND VGND VPWR VPWR sky130_fd_sc_hd__decap_3
XTAP_TAPCELL_ROW_47_875 VGND VPWR sky130_fd_sc_hd__tapvpwrvgnd_1
XFILLER_24_519 VGND VGND VPWR VPWR sky130_fd_sc_hd__decap_3
X_4971_ _4811_/C _4949_/Y _4967_/X _4969_/X _4970_/X VGND VGND VPWR VPWR _5661_/B
+ sky130_fd_sc_hd__a311oi_2
XFILLER_64_699 VGND VGND VPWR VPWR sky130_fd_sc_hd__fill_1
XFILLER_63_187 VGND VGND VPWR VPWR sky130_fd_sc_hd__decap_3
XFILLER_17_582 VGND VGND VPWR VPWR sky130_fd_sc_hd__decap_3
X_6710_ _6965_/CLK _6710_/D VGND VGND VPWR VPWR _6710_/Q sky130_fd_sc_hd__dfxtp_2
X_3922_ _6778_/Q _3926_/B1 _3665_/X _6866_/Q _3921_/X VGND VGND VPWR VPWR _3922_/X
+ sky130_fd_sc_hd__a221o_2
X_3853_ _6736_/Q _3893_/A2 _3893_/B1 _6730_/Q _3852_/X VGND VGND VPWR VPWR _3853_/X
+ sky130_fd_sc_hd__a221o_2
X_6641_ _6642_/A VGND VGND VPWR VPWR _6641_/Y sky130_fd_sc_hd__inv_2
XFILLER_32_574 VGND VGND VPWR VPWR sky130_fd_sc_hd__decap_3
XFILLER_20_725 VGND VGND VPWR VPWR sky130_fd_sc_hd__decap_3
XTAP_TAPCELL_ROW_63_1088 VGND VPWR sky130_fd_sc_hd__tapvpwrvgnd_1
XTAP_TAPCELL_ROW_119_1811 VGND VPWR sky130_fd_sc_hd__tapvpwrvgnd_1
X_3784_ _6847_/Q _3661_/X _3892_/B1 _6842_/Q VGND VGND VPWR VPWR _3784_/X sky130_fd_sc_hd__a22o_2
X_6572_ _6608_/A VGND VGND VPWR VPWR _6572_/Y sky130_fd_sc_hd__inv_2
XFILLER_118_613 VGND VGND VPWR VPWR sky130_fd_sc_hd__decap_3
XFILLER_8_280 VGND VGND VPWR VPWR sky130_fd_sc_hd__decap_3
XFILLER_118_657 VGND VGND VPWR VPWR sky130_fd_sc_hd__decap_3
Xoutput500 _5641_/Y VGND VGND VPWR VPWR instruction_out[17] sky130_fd_sc_hd__clkdlybuf4s25_1
XFILLER_117_167 VGND VGND VPWR VPWR sky130_fd_sc_hd__fill_1
Xoutput511 _4791_/C1 VGND VGND VPWR VPWR instruction_out[2] sky130_fd_sc_hd__clkdlybuf4s25_1
Xoutput522 _6988_/Q VGND VGND VPWR VPWR pc_out[11] sky130_fd_sc_hd__clkdlybuf4s25_1
X_4405_ _7242_/Q _4433_/B _3945_/S _7210_/Q VGND VGND VPWR VPWR _4405_/X sky130_fd_sc_hd__a22o_2
Xoutput533 _6998_/Q VGND VGND VPWR VPWR pc_out[21] sky130_fd_sc_hd__clkdlybuf4s25_1
Xoutput544 _7008_/Q VGND VGND VPWR VPWR pc_out[31] sky130_fd_sc_hd__clkdlybuf4s25_1
XFILLER_99_541 VGND VGND VPWR VPWR sky130_fd_sc_hd__fill_1
X_4336_ _4336_/A _4336_/B _4336_/C VGND VGND VPWR VPWR _4336_/X sky130_fd_sc_hd__or3_2
X_7124_ _7279_/CLK _7124_/D _6404_/Y VGND VGND VPWR VPWR _7124_/Q sky130_fd_sc_hd__dfrtp_2
XFILLER_87_703 VGND VGND VPWR VPWR sky130_fd_sc_hd__decap_3
XFILLER_113_340 VGND VGND VPWR VPWR sky130_fd_sc_hd__decap_3
XFILLER_59_405 VGND VGND VPWR VPWR sky130_fd_sc_hd__decap_3
XFILLER_99_585 VGND VGND VPWR VPWR sky130_fd_sc_hd__decap_3
XFILLER_113_362 VGND VGND VPWR VPWR sky130_fd_sc_hd__decap_3
XFILLER_115_37 VGND VGND VPWR VPWR sky130_fd_sc_hd__decap_3
X_7055_ _7279_/CLK _7055_/D _6335_/Y VGND VGND VPWR VPWR _7055_/Q sky130_fd_sc_hd__dfrtp_2
XFILLER_86_224 VGND VGND VPWR VPWR sky130_fd_sc_hd__decap_3
X_4267_ _7134_/Q _4267_/A2 _4267_/B1 _7166_/Q VGND VGND VPWR VPWR _4271_/B sky130_fd_sc_hd__a22o_2
XFILLER_59_449 VGND VGND VPWR VPWR sky130_fd_sc_hd__decap_3
XFILLER_86_268 VGND VGND VPWR VPWR sky130_fd_sc_hd__decap_3
XFILLER_101_579 VGND VGND VPWR VPWR sky130_fd_sc_hd__decap_3
X_4198_ _4194_/X _4197_/X _4327_/A VGND VGND VPWR VPWR _4380_/B sky130_fd_sc_hd__o21ai_2
XFILLER_67_482 VGND VGND VPWR VPWR sky130_fd_sc_hd__decap_3
XFILLER_55_644 VGND VGND VPWR VPWR sky130_fd_sc_hd__decap_3
XFILLER_27_335 VGND VGND VPWR VPWR sky130_fd_sc_hd__fill_1
XFILLER_27_346 VGND VGND VPWR VPWR sky130_fd_sc_hd__decap_3
XFILLER_82_452 VGND VGND VPWR VPWR sky130_fd_sc_hd__decap_3
XFILLER_15_508 VGND VGND VPWR VPWR sky130_fd_sc_hd__decap_3
XFILLER_55_688 VGND VGND VPWR VPWR sky130_fd_sc_hd__decap_3
XFILLER_27_379 VGND VGND VPWR VPWR sky130_fd_sc_hd__decap_3
XFILLER_70_625 VGND VGND VPWR VPWR sky130_fd_sc_hd__decap_3
X_6908_ _6942_/CLK _6908_/D VGND VGND VPWR VPWR _6908_/Q sky130_fd_sc_hd__dfxtp_2
XFILLER_70_669 VGND VGND VPWR VPWR sky130_fd_sc_hd__decap_3
XFILLER_35_390 VGND VGND VPWR VPWR sky130_fd_sc_hd__fill_2
XFILLER_11_703 VGND VGND VPWR VPWR sky130_fd_sc_hd__decap_3
XFILLER_23_574 VGND VGND VPWR VPWR sky130_fd_sc_hd__decap_3
X_6839_ clkload5/A _6839_/D VGND VGND VPWR VPWR _6839_/Q sky130_fd_sc_hd__dfxtp_2
XFILLER_50_360 VGND VGND VPWR VPWR sky130_fd_sc_hd__decap_3
XFILLER_10_213 VGND VGND VPWR VPWR sky130_fd_sc_hd__fill_1
XFILLER_7_718 VGND VGND VPWR VPWR sky130_fd_sc_hd__decap_3
XFILLER_7_729 VGND VGND VPWR VPWR sky130_fd_sc_hd__decap_3
XFILLER_6_206 VGND VGND VPWR VPWR sky130_fd_sc_hd__decap_3
XFILLER_108_101 VGND VGND VPWR VPWR sky130_fd_sc_hd__decap_3
XFILLER_40_22 VGND VGND VPWR VPWR sky130_fd_sc_hd__decap_3
XFILLER_109_635 VGND VGND VPWR VPWR sky130_fd_sc_hd__decap_3
XFILLER_40_55 VGND VGND VPWR VPWR sky130_fd_sc_hd__fill_2
XFILLER_109_668 VGND VGND VPWR VPWR sky130_fd_sc_hd__decap_3
XFILLER_109_679 VGND VGND VPWR VPWR sky130_fd_sc_hd__decap_3
XFILLER_40_88 VGND VGND VPWR VPWR sky130_fd_sc_hd__decap_3
XFILLER_123_104 VGND VGND VPWR VPWR sky130_fd_sc_hd__decap_3
XFILLER_6_3 VGND VGND VPWR VPWR sky130_fd_sc_hd__decap_3
XFILLER_123_137 VGND VGND VPWR VPWR sky130_fd_sc_hd__decap_3
XFILLER_49_31 VGND VGND VPWR VPWR sky130_fd_sc_hd__decap_3
XFILLER_78_725 VGND VGND VPWR VPWR sky130_fd_sc_hd__decap_3
XFILLER_77_202 VGND VGND VPWR VPWR sky130_fd_sc_hd__decap_3
XFILLER_104_395 VGND VGND VPWR VPWR sky130_fd_sc_hd__fill_2
XFILLER_93_706 VGND VGND VPWR VPWR sky130_fd_sc_hd__decap_3
XFILLER_77_268 VGND VGND VPWR VPWR sky130_fd_sc_hd__decap_3
XFILLER_65_419 VGND VGND VPWR VPWR sky130_fd_sc_hd__decap_3
XFILLER_58_471 VGND VGND VPWR VPWR sky130_fd_sc_hd__decap_3
XFILLER_46_611 VGND VGND VPWR VPWR sky130_fd_sc_hd__decap_3
XFILLER_18_302 VGND VGND VPWR VPWR sky130_fd_sc_hd__decap_3
XFILLER_92_238 VGND VGND VPWR VPWR sky130_fd_sc_hd__decap_3
XFILLER_85_290 VGND VGND VPWR VPWR sky130_fd_sc_hd__decap_3
XFILLER_65_52 VGND VGND VPWR VPWR sky130_fd_sc_hd__decap_3
XFILLER_65_63 VGND VGND VPWR VPWR sky130_fd_sc_hd__decap_3
XFILLER_73_452 VGND VGND VPWR VPWR sky130_fd_sc_hd__fill_2
XFILLER_46_666 VGND VGND VPWR VPWR sky130_fd_sc_hd__decap_3
XFILLER_73_463 VGND VGND VPWR VPWR sky130_fd_sc_hd__decap_3
XFILLER_18_368 VGND VGND VPWR VPWR sky130_fd_sc_hd__decap_3
XFILLER_61_614 VGND VGND VPWR VPWR sky130_fd_sc_hd__fill_2
XFILLER_46_699 VGND VGND VPWR VPWR sky130_fd_sc_hd__fill_1
XTAP_TAPCELL_ROW_103_1601 VGND VPWR sky130_fd_sc_hd__tapvpwrvgnd_1
XFILLER_73_485 VGND VGND VPWR VPWR sky130_fd_sc_hd__decap_3
XFILLER_60_102 VGND VGND VPWR VPWR sky130_fd_sc_hd__fill_2
XFILLER_33_316 VGND VGND VPWR VPWR sky130_fd_sc_hd__decap_3
XFILLER_45_187 VGND VGND VPWR VPWR sky130_fd_sc_hd__decap_3
XTAP_TAPCELL_ROW_103_1612 VGND VPWR sky130_fd_sc_hd__tapvpwrvgnd_1
XTAP_TAPCELL_ROW_44_834 VGND VPWR sky130_fd_sc_hd__tapvpwrvgnd_1
XFILLER_61_647 VGND VGND VPWR VPWR sky130_fd_sc_hd__decap_3
XFILLER_60_124 VGND VGND VPWR VPWR sky130_fd_sc_hd__decap_3
XTAP_TAPCELL_ROW_44_845 VGND VPWR sky130_fd_sc_hd__tapvpwrvgnd_1
XFILLER_33_349 VGND VGND VPWR VPWR sky130_fd_sc_hd__decap_3
XFILLER_14_552 VGND VGND VPWR VPWR sky130_fd_sc_hd__decap_3
XFILLER_60_168 VGND VGND VPWR VPWR sky130_fd_sc_hd__decap_3
XFILLER_14_585 VGND VGND VPWR VPWR sky130_fd_sc_hd__decap_3
XTAP_TAPCELL_ROW_24_580 VGND VPWR sky130_fd_sc_hd__tapvpwrvgnd_1
XFILLER_115_638 VGND VGND VPWR VPWR sky130_fd_sc_hd__decap_3
XFILLER_108_690 VGND VGND VPWR VPWR sky130_fd_sc_hd__decap_3
XTAP_TAPCELL_ROW_114_1752 VGND VPWR sky130_fd_sc_hd__tapvpwrvgnd_1
XFILLER_69_703 VGND VGND VPWR VPWR sky130_fd_sc_hd__decap_3
XFILLER_123_671 VGND VGND VPWR VPWR sky130_fd_sc_hd__fill_1
X_4121_ _7140_/Q _4267_/A2 _4267_/B1 _7172_/Q _4120_/X VGND VGND VPWR VPWR _4121_/X
+ sky130_fd_sc_hd__a221o_2
XFILLER_96_533 VGND VGND VPWR VPWR sky130_fd_sc_hd__fill_1
XFILLER_96_566 VGND VGND VPWR VPWR sky130_fd_sc_hd__decap_3
XFILLER_68_268 VGND VGND VPWR VPWR sky130_fd_sc_hd__decap_3
XFILLER_56_408 VGND VGND VPWR VPWR sky130_fd_sc_hd__decap_3
X_4052_ _4047_/X _4050_/X _4425_/A VGND VGND VPWR VPWR _4456_/A sky130_fd_sc_hd__o21a_2
XFILLER_84_728 VGND VGND VPWR VPWR sky130_fd_sc_hd__decap_3
XFILLER_110_365 VGND VGND VPWR VPWR sky130_fd_sc_hd__decap_3
XFILLER_37_600 VGND VGND VPWR VPWR sky130_fd_sc_hd__decap_3
XFILLER_83_216 VGND VGND VPWR VPWR sky130_fd_sc_hd__decap_3
XFILLER_83_249 VGND VGND VPWR VPWR sky130_fd_sc_hd__decap_3
XFILLER_37_644 VGND VGND VPWR VPWR sky130_fd_sc_hd__decap_3
XFILLER_64_441 VGND VGND VPWR VPWR sky130_fd_sc_hd__decap_3
XTAP_TAPCELL_ROW_65_1106 VGND VPWR sky130_fd_sc_hd__tapvpwrvgnd_1
XFILLER_37_688 VGND VGND VPWR VPWR sky130_fd_sc_hd__decap_3
XTAP_TAPCELL_ROW_65_1117 VGND VPWR sky130_fd_sc_hd__tapvpwrvgnd_1
XFILLER_52_625 VGND VGND VPWR VPWR sky130_fd_sc_hd__decap_3
XFILLER_51_102 VGND VGND VPWR VPWR sky130_fd_sc_hd__fill_2
XFILLER_36_176 VGND VGND VPWR VPWR sky130_fd_sc_hd__fill_1
XFILLER_36_187 VGND VGND VPWR VPWR sky130_fd_sc_hd__fill_1
XFILLER_91_293 VGND VGND VPWR VPWR sky130_fd_sc_hd__fill_2
X_4954_ _4200_/A _4969_/C _4953_/Y _4200_/X VGND VGND VPWR VPWR _4954_/X sky130_fd_sc_hd__o211a_2
XFILLER_52_669 VGND VGND VPWR VPWR sky130_fd_sc_hd__decap_3
X_3905_ _3905_/A1 _5104_/A _3904_/Y VGND VGND VPWR VPWR _7380_/D sky130_fd_sc_hd__a21bo_2
XFILLER_32_360 VGND VGND VPWR VPWR sky130_fd_sc_hd__decap_3
X_4885_ _4904_/B _4903_/A VGND VGND VPWR VPWR _4886_/C sky130_fd_sc_hd__and2b_2
XFILLER_32_371 VGND VGND VPWR VPWR sky130_fd_sc_hd__decap_3
XFILLER_20_533 VGND VGND VPWR VPWR sky130_fd_sc_hd__fill_2
X_6624_ _6624_/A VGND VGND VPWR VPWR _6624_/Y sky130_fd_sc_hd__inv_2
X_3836_ _6970_/Q _3893_/B1 _3850_/B1 _6720_/Q _3835_/X VGND VGND VPWR VPWR _3836_/X
+ sky130_fd_sc_hd__a221o_2
XFILLER_20_566 VGND VGND VPWR VPWR sky130_fd_sc_hd__decap_3
XFILLER_118_421 VGND VGND VPWR VPWR sky130_fd_sc_hd__decap_3
X_3767_ _6705_/Q _3767_/A2 _3871_/B1 _6883_/Q VGND VGND VPWR VPWR _3767_/X sky130_fd_sc_hd__a22o_2
X_6555_ _6556_/A VGND VGND VPWR VPWR _6555_/Y sky130_fd_sc_hd__inv_2
XFILLER_106_616 VGND VGND VPWR VPWR sky130_fd_sc_hd__decap_3
X_3698_ _3698_/A1 _4799_/A _3697_/Y VGND VGND VPWR VPWR _7402_/D sky130_fd_sc_hd__o21ba_2
X_6486_ _6643_/A VGND VGND VPWR VPWR _6486_/Y sky130_fd_sc_hd__inv_2
XFILLER_118_498 VGND VGND VPWR VPWR sky130_fd_sc_hd__decap_3
XTAP_TAPCELL_ROW_76_1257 VGND VPWR sky130_fd_sc_hd__tapvpwrvgnd_1
XPHY_EDGE_ROW_5_Left_129 VGND VGND VPWR VPWR sky130_fd_sc_hd__decap_3
XFILLER_114_660 VGND VGND VPWR VPWR sky130_fd_sc_hd__decap_3
XFILLER_86_18 VGND VGND VPWR VPWR sky130_fd_sc_hd__fill_2
XFILLER_86_29 VGND VGND VPWR VPWR sky130_fd_sc_hd__decap_3
XFILLER_59_213 VGND VGND VPWR VPWR sky130_fd_sc_hd__decap_3
XFILLER_114_693 VGND VGND VPWR VPWR sky130_fd_sc_hd__decap_3
X_7107_ _7365_/CLK _7107_/D _6387_/Y VGND VGND VPWR VPWR _7107_/Q sky130_fd_sc_hd__dfrtp_2
XFILLER_99_393 VGND VGND VPWR VPWR sky130_fd_sc_hd__fill_1
X_4319_ _7258_/Q _4356_/A2 _4316_/X _4318_/X VGND VGND VPWR VPWR _4362_/A sky130_fd_sc_hd__a211o_2
XFILLER_75_706 VGND VGND VPWR VPWR sky130_fd_sc_hd__decap_3
XFILLER_47_408 VGND VGND VPWR VPWR sky130_fd_sc_hd__decap_3
X_7038_ _7386_/CLK _7038_/D _6318_/Y VGND VGND VPWR VPWR _7038_/Q sky130_fd_sc_hd__dfrtp_2
XFILLER_87_588 VGND VGND VPWR VPWR sky130_fd_sc_hd__decap_3
XFILLER_101_365 VGND VGND VPWR VPWR sky130_fd_sc_hd__decap_3
XFILLER_74_227 VGND VGND VPWR VPWR sky130_fd_sc_hd__fill_2
XFILLER_19_67 VGND VGND VPWR VPWR sky130_fd_sc_hd__decap_3
XFILLER_28_622 VGND VGND VPWR VPWR sky130_fd_sc_hd__decap_3
XFILLER_67_290 VGND VGND VPWR VPWR sky130_fd_sc_hd__fill_1
XFILLER_28_666 VGND VGND VPWR VPWR sky130_fd_sc_hd__decap_3
XFILLER_43_614 VGND VGND VPWR VPWR sky130_fd_sc_hd__fill_2
XTAP_TAPCELL_ROW_2_297 VGND VPWR sky130_fd_sc_hd__tapvpwrvgnd_1
XFILLER_28_699 VGND VGND VPWR VPWR sky130_fd_sc_hd__fill_1
XFILLER_82_271 VGND VGND VPWR VPWR sky130_fd_sc_hd__decap_3
XFILLER_15_327 VGND VGND VPWR VPWR sky130_fd_sc_hd__decap_3
XTAP_TAPCELL_ROW_87_1397 VGND VPWR sky130_fd_sc_hd__tapvpwrvgnd_1
XFILLER_43_647 VGND VGND VPWR VPWR sky130_fd_sc_hd__decap_3
XFILLER_35_66 VGND VGND VPWR VPWR sky130_fd_sc_hd__decap_3
XFILLER_15_349 VGND VGND VPWR VPWR sky130_fd_sc_hd__fill_2
XFILLER_42_157 VGND VGND VPWR VPWR sky130_fd_sc_hd__decap_3
XFILLER_35_88 VGND VGND VPWR VPWR sky130_fd_sc_hd__decap_3
XTAP_TAPCELL_ROW_41_804 VGND VPWR sky130_fd_sc_hd__tapvpwrvgnd_1
XFILLER_70_477 VGND VGND VPWR VPWR sky130_fd_sc_hd__decap_3
XFILLER_42_179 VGND VGND VPWR VPWR sky130_fd_sc_hd__decap_3
XFILLER_11_500 VGND VGND VPWR VPWR sky130_fd_sc_hd__decap_3
XFILLER_51_691 VGND VGND VPWR VPWR sky130_fd_sc_hd__decap_3
XFILLER_23_393 VGND VGND VPWR VPWR sky130_fd_sc_hd__decap_3
XFILLER_11_544 VGND VGND VPWR VPWR sky130_fd_sc_hd__decap_3
XFILLER_50_190 VGND VGND VPWR VPWR sky130_fd_sc_hd__decap_3
XFILLER_7_515 VGND VGND VPWR VPWR sky130_fd_sc_hd__decap_3
XFILLER_11_588 VGND VGND VPWR VPWR sky130_fd_sc_hd__decap_3
XFILLER_7_548 VGND VGND VPWR VPWR sky130_fd_sc_hd__decap_3
XFILLER_3_721 VGND VGND VPWR VPWR sky130_fd_sc_hd__decap_3
XFILLER_3_732 VGND VGND VPWR VPWR sky130_fd_sc_hd__decap_3
XFILLER_97_308 VGND VGND VPWR VPWR sky130_fd_sc_hd__decap_3
XFILLER_112_619 VGND VGND VPWR VPWR sky130_fd_sc_hd__decap_3
XFILLER_105_671 VGND VGND VPWR VPWR sky130_fd_sc_hd__fill_1
XFILLER_105_682 VGND VGND VPWR VPWR sky130_fd_sc_hd__decap_3
XFILLER_78_533 VGND VGND VPWR VPWR sky130_fd_sc_hd__fill_1
XFILLER_104_181 VGND VGND VPWR VPWR sky130_fd_sc_hd__decap_3
XFILLER_116_80 VGND VGND VPWR VPWR sky130_fd_sc_hd__decap_3
XTAP_TAPCELL_ROW_49_904 VGND VPWR sky130_fd_sc_hd__tapvpwrvgnd_1
XFILLER_78_566 VGND VGND VPWR VPWR sky130_fd_sc_hd__decap_3
XFILLER_38_408 VGND VGND VPWR VPWR sky130_fd_sc_hd__fill_1
XFILLER_120_663 VGND VGND VPWR VPWR sky130_fd_sc_hd__decap_3
XFILLER_116_91 VGND VGND VPWR VPWR sky130_fd_sc_hd__decap_3
XFILLER_66_728 VGND VGND VPWR VPWR sky130_fd_sc_hd__decap_3
XFILLER_19_600 VGND VGND VPWR VPWR sky130_fd_sc_hd__decap_3
XFILLER_65_216 VGND VGND VPWR VPWR sky130_fd_sc_hd__decap_3
XFILLER_120_696 VGND VGND VPWR VPWR sky130_fd_sc_hd__decap_3
XFILLER_93_547 VGND VGND VPWR VPWR sky130_fd_sc_hd__decap_3
XFILLER_65_249 VGND VGND VPWR VPWR sky130_fd_sc_hd__decap_3
XFILLER_19_644 VGND VGND VPWR VPWR sky130_fd_sc_hd__decap_3
XFILLER_81_709 VGND VGND VPWR VPWR sky130_fd_sc_hd__decap_3
XFILLER_18_121 VGND VGND VPWR VPWR sky130_fd_sc_hd__fill_2
XTAP_TAPCELL_ROW_29_650 VGND VPWR sky130_fd_sc_hd__tapvpwrvgnd_1
XFILLER_19_688 VGND VGND VPWR VPWR sky130_fd_sc_hd__decap_3
XFILLER_34_625 VGND VGND VPWR VPWR sky130_fd_sc_hd__decap_3
XFILLER_61_433 VGND VGND VPWR VPWR sky130_fd_sc_hd__decap_3
XFILLER_73_293 VGND VGND VPWR VPWR sky130_fd_sc_hd__decap_3
XFILLER_34_669 VGND VGND VPWR VPWR sky130_fd_sc_hd__decap_3
XFILLER_61_455 VGND VGND VPWR VPWR sky130_fd_sc_hd__decap_3
XFILLER_92_94 VGND VGND VPWR VPWR sky130_fd_sc_hd__decap_3
XFILLER_61_488 VGND VGND VPWR VPWR sky130_fd_sc_hd__fill_2
XFILLER_14_371 VGND VGND VPWR VPWR sky130_fd_sc_hd__decap_3
X_4670_ _6995_/Q _4690_/B VGND VGND VPWR VPWR _4682_/B sky130_fd_sc_hd__or2_2
XTAP_TAPCELL_ROW_60_1047 VGND VPWR sky130_fd_sc_hd__tapvpwrvgnd_1
X_3621_ _3621_/A _3621_/B VGND VGND VPWR VPWR _4852_/A sky130_fd_sc_hd__nand2_2
X_3552_ _3508_/Y _5020_/A _3620_/A _3537_/X _3551_/X VGND VGND VPWR VPWR _3746_/A
+ sky130_fd_sc_hd__o311a_2
X_6340_ _6660_/A VGND VGND VPWR VPWR _6340_/Y sky130_fd_sc_hd__inv_2
XFILLER_6_581 VGND VGND VPWR VPWR sky130_fd_sc_hd__decap_3
XFILLER_115_424 VGND VGND VPWR VPWR sky130_fd_sc_hd__decap_3
X_6271_ _6275_/A VGND VGND VPWR VPWR _6271_/Y sky130_fd_sc_hd__inv_2
XFILLER_6_592 VGND VGND VPWR VPWR sky130_fd_sc_hd__decap_3
X_3483_ _3442_/A _3442_/B _3409_/D VGND VGND VPWR VPWR _5153_/B sky130_fd_sc_hd__a21o_2
XFILLER_102_129 VGND VGND VPWR VPWR sky130_fd_sc_hd__decap_3
X_5153_ _7010_/D _5153_/B VGND VGND VPWR VPWR _5153_/X sky130_fd_sc_hd__xor2_2
XFILLER_96_341 VGND VGND VPWR VPWR sky130_fd_sc_hd__decap_3
XFILLER_111_641 VGND VGND VPWR VPWR sky130_fd_sc_hd__decap_3
XFILLER_57_706 VGND VGND VPWR VPWR sky130_fd_sc_hd__decap_3
X_4104_ _7237_/Q _4433_/B _4497_/S _7050_/Q VGND VGND VPWR VPWR _4104_/X sky130_fd_sc_hd__a22o_2
XFILLER_84_503 VGND VGND VPWR VPWR sky130_fd_sc_hd__fill_1
XTAP_TAPCELL_ROW_71_1187 VGND VPWR sky130_fd_sc_hd__tapvpwrvgnd_1
X_5084_ _4343_/X _5084_/B _5086_/A VGND VGND VPWR VPWR _5084_/X sky130_fd_sc_hd__and3b_2
XFILLER_111_685 VGND VGND VPWR VPWR sky130_fd_sc_hd__decap_3
XFILLER_84_525 VGND VGND VPWR VPWR sky130_fd_sc_hd__decap_3
XFILLER_110_162 VGND VGND VPWR VPWR sky130_fd_sc_hd__decap_3
XFILLER_110_173 VGND VGND VPWR VPWR sky130_fd_sc_hd__decap_3
XFILLER_56_238 VGND VGND VPWR VPWR sky130_fd_sc_hd__decap_3
X_4035_ _7374_/Q _4108_/B _4436_/B1 _7182_/Q _4034_/X VGND VGND VPWR VPWR _4035_/X
+ sky130_fd_sc_hd__a221o_2
XFILLER_49_290 VGND VGND VPWR VPWR sky130_fd_sc_hd__decap_3
XFILLER_37_441 VGND VGND VPWR VPWR sky130_fd_sc_hd__decap_3
XFILLER_37_452 VGND VGND VPWR VPWR sky130_fd_sc_hd__decap_3
XFILLER_25_603 VGND VGND VPWR VPWR sky130_fd_sc_hd__decap_3
XFILLER_37_474 VGND VGND VPWR VPWR sky130_fd_sc_hd__fill_1
XFILLER_112_38 VGND VGND VPWR VPWR sky130_fd_sc_hd__decap_3
XFILLER_52_411 VGND VGND VPWR VPWR sky130_fd_sc_hd__decap_3
XFILLER_37_485 VGND VGND VPWR VPWR sky130_fd_sc_hd__decap_3
XFILLER_92_580 VGND VGND VPWR VPWR sky130_fd_sc_hd__decap_3
XFILLER_64_271 VGND VGND VPWR VPWR sky130_fd_sc_hd__decap_3
XFILLER_80_731 VGND VGND VPWR VPWR sky130_fd_sc_hd__decap_3
XFILLER_25_647 VGND VGND VPWR VPWR sky130_fd_sc_hd__decap_3
XFILLER_24_124 VGND VGND VPWR VPWR sky130_fd_sc_hd__decap_3
XFILLER_52_455 VGND VGND VPWR VPWR sky130_fd_sc_hd__decap_3
XFILLER_52_477 VGND VGND VPWR VPWR sky130_fd_sc_hd__decap_3
XFILLER_24_168 VGND VGND VPWR VPWR sky130_fd_sc_hd__decap_3
XFILLER_40_628 VGND VGND VPWR VPWR sky130_fd_sc_hd__decap_3
XFILLER_12_319 VGND VGND VPWR VPWR sky130_fd_sc_hd__decap_3
X_4937_ _4937_/A _4937_/B VGND VGND VPWR VPWR _4937_/Y sky130_fd_sc_hd__xnor2_2
XFILLER_33_691 VGND VGND VPWR VPWR sky130_fd_sc_hd__decap_3
XFILLER_20_330 VGND VGND VPWR VPWR sky130_fd_sc_hd__fill_2
X_4868_ _6999_/Q _4882_/A VGND VGND VPWR VPWR _6999_/D sky130_fd_sc_hd__xnor2_2
XFILLER_20_363 VGND VGND VPWR VPWR sky130_fd_sc_hd__fill_1
X_6607_ _6612_/A VGND VGND VPWR VPWR _6607_/Y sky130_fd_sc_hd__inv_2
X_3819_ _6791_/Q _3898_/B1 _3871_/B1 _6879_/Q VGND VGND VPWR VPWR _3819_/X sky130_fd_sc_hd__a22o_2
X_4799_ _4799_/A _5656_/A VGND VGND VPWR VPWR _4799_/X sky130_fd_sc_hd__or2_2
XFILLER_118_251 VGND VGND VPWR VPWR sky130_fd_sc_hd__fill_1
X_6538_ _6633_/A VGND VGND VPWR VPWR _6538_/Y sky130_fd_sc_hd__inv_2
XFILLER_21_57 VGND VGND VPWR VPWR sky130_fd_sc_hd__decap_3
XFILLER_118_262 VGND VGND VPWR VPWR sky130_fd_sc_hd__decap_3
X_6469_ _6658_/A VGND VGND VPWR VPWR _6469_/Y sky130_fd_sc_hd__inv_2
XFILLER_0_713 VGND VGND VPWR VPWR sky130_fd_sc_hd__decap_3
XFILLER_121_449 VGND VGND VPWR VPWR sky130_fd_sc_hd__decap_3
XTAP_TAPCELL_ROW_7_356 VGND VPWR sky130_fd_sc_hd__tapvpwrvgnd_1
XFILLER_99_190 VGND VGND VPWR VPWR sky130_fd_sc_hd__decap_3
XPHY_EDGE_ROW_102_Right_102 VGND VGND VPWR VPWR sky130_fd_sc_hd__decap_3
XFILLER_102_663 VGND VGND VPWR VPWR sky130_fd_sc_hd__decap_3
XFILLER_48_728 VGND VGND VPWR VPWR sky130_fd_sc_hd__decap_3
XTAP_TAPCELL_ROW_89_1426 VGND VPWR sky130_fd_sc_hd__tapvpwrvgnd_1
XFILLER_75_536 VGND VGND VPWR VPWR sky130_fd_sc_hd__decap_3
XFILLER_102_696 VGND VGND VPWR VPWR sky130_fd_sc_hd__decap_3
XFILLER_87_396 VGND VGND VPWR VPWR sky130_fd_sc_hd__decap_3
XFILLER_63_709 VGND VGND VPWR VPWR sky130_fd_sc_hd__decap_3
XFILLER_46_32 VGND VGND VPWR VPWR sky130_fd_sc_hd__fill_2
XFILLER_90_506 VGND VGND VPWR VPWR sky130_fd_sc_hd__decap_3
XFILLER_28_474 VGND VGND VPWR VPWR sky130_fd_sc_hd__fill_2
XFILLER_16_625 VGND VGND VPWR VPWR sky130_fd_sc_hd__decap_3
XFILLER_83_591 VGND VGND VPWR VPWR sky130_fd_sc_hd__decap_3
XFILLER_15_113 VGND VGND VPWR VPWR sky130_fd_sc_hd__decap_3
XFILLER_43_455 VGND VGND VPWR VPWR sky130_fd_sc_hd__decap_3
XFILLER_16_669 VGND VGND VPWR VPWR sky130_fd_sc_hd__decap_3
XFILLER_31_606 VGND VGND VPWR VPWR sky130_fd_sc_hd__decap_3
XTAP_TAPCELL_ROW_54_973 VGND VPWR sky130_fd_sc_hd__tapvpwrvgnd_1
XFILLER_31_617 VGND VGND VPWR VPWR sky130_fd_sc_hd__decap_3
XFILLER_70_296 VGND VGND VPWR VPWR sky130_fd_sc_hd__decap_3
XFILLER_30_138 VGND VGND VPWR VPWR sky130_fd_sc_hd__fill_2
XFILLER_7_37 VGND VGND VPWR VPWR sky130_fd_sc_hd__fill_2
XFILLER_7_323 VGND VGND VPWR VPWR sky130_fd_sc_hd__decap_3
XFILLER_11_396 VGND VGND VPWR VPWR sky130_fd_sc_hd__decap_3
XFILLER_109_284 VGND VGND VPWR VPWR sky130_fd_sc_hd__decap_3
XFILLER_109_295 VGND VGND VPWR VPWR sky130_fd_sc_hd__decap_3
XFILLER_112_405 VGND VGND VPWR VPWR sky130_fd_sc_hd__decap_3
XTAP_TAPCELL_ROW_111_1711 VGND VPWR sky130_fd_sc_hd__tapvpwrvgnd_1
XFILLER_98_628 VGND VGND VPWR VPWR sky130_fd_sc_hd__decap_3
XFILLER_3_573 VGND VGND VPWR VPWR sky130_fd_sc_hd__decap_3
XFILLER_112_427 VGND VGND VPWR VPWR sky130_fd_sc_hd__decap_3
XFILLER_105_490 VGND VGND VPWR VPWR sky130_fd_sc_hd__decap_3
XFILLER_39_706 VGND VGND VPWR VPWR sky130_fd_sc_hd__decap_3
XFILLER_66_514 VGND VGND VPWR VPWR sky130_fd_sc_hd__fill_1
XFILLER_120_460 VGND VGND VPWR VPWR sky130_fd_sc_hd__decap_3
XFILLER_78_396 VGND VGND VPWR VPWR sky130_fd_sc_hd__decap_3
XFILLER_66_536 VGND VGND VPWR VPWR sky130_fd_sc_hd__decap_3
XFILLER_93_333 VGND VGND VPWR VPWR sky130_fd_sc_hd__decap_3
XFILLER_66_547 VGND VGND VPWR VPWR sky130_fd_sc_hd__decap_3
XFILLER_38_238 VGND VGND VPWR VPWR sky130_fd_sc_hd__decap_3
XFILLER_53_208 VGND VGND VPWR VPWR sky130_fd_sc_hd__decap_3
XTAP_TAPCELL_ROW_109_1684 VGND VPWR sky130_fd_sc_hd__tapvpwrvgnd_1
XFILLER_46_271 VGND VGND VPWR VPWR sky130_fd_sc_hd__decap_3
XFILLER_19_485 VGND VGND VPWR VPWR sky130_fd_sc_hd__decap_3
XFILLER_62_731 VGND VGND VPWR VPWR sky130_fd_sc_hd__decap_3
XFILLER_34_433 VGND VGND VPWR VPWR sky130_fd_sc_hd__decap_3
XFILLER_34_466 VGND VGND VPWR VPWR sky130_fd_sc_hd__decap_3
XTAP_TAPCELL_ROW_122_1851 VGND VPWR sky130_fd_sc_hd__tapvpwrvgnd_1
XFILLER_34_477 VGND VGND VPWR VPWR sky130_fd_sc_hd__decap_3
XFILLER_22_628 VGND VGND VPWR VPWR sky130_fd_sc_hd__decap_3
XFILLER_61_296 VGND VGND VPWR VPWR sky130_fd_sc_hd__fill_1
XFILLER_15_691 VGND VGND VPWR VPWR sky130_fd_sc_hd__decap_3
XTAP_TAPCELL_ROW_32_678 VGND VPWR sky130_fd_sc_hd__tapvpwrvgnd_1
XTAP_TAPCELL_ROW_32_689 VGND VPWR sky130_fd_sc_hd__tapvpwrvgnd_1
XFILLER_30_672 VGND VGND VPWR VPWR sky130_fd_sc_hd__decap_3
X_4653_ _4648_/Y _4785_/A _4413_/A _4397_/A VGND VGND VPWR VPWR _4653_/Y sky130_fd_sc_hd__a211oi_2
X_3604_ _4938_/A _5114_/A VGND VGND VPWR VPWR _3621_/B sky130_fd_sc_hd__nor2_2
X_7372_ _7372_/CLK _7372_/D _6652_/Y VGND VGND VPWR VPWR _7372_/Q sky130_fd_sc_hd__dfrtp_2
Xhold802 _6842_/Q VGND VGND VPWR VPWR _6842_/D sky130_fd_sc_hd__dlygate4sd3_1
XFILLER_116_722 VGND VGND VPWR VPWR sky130_fd_sc_hd__decap_3
Xhold813 _6812_/Q VGND VGND VPWR VPWR _6812_/D sky130_fd_sc_hd__dlygate4sd3_1
X_6323_ _6642_/A VGND VGND VPWR VPWR _6323_/Y sky130_fd_sc_hd__inv_2
Xhold824 _6843_/Q VGND VGND VPWR VPWR _6843_/D sky130_fd_sc_hd__dlygate4sd3_1
X_3535_ _3621_/A _3535_/B _4764_/B VGND VGND VPWR VPWR _3536_/B sky130_fd_sc_hd__and3_2
Xhold835 _6970_/Q VGND VGND VPWR VPWR _6970_/D sky130_fd_sc_hd__dlygate4sd3_1
Xmax_cap554 _4619_/Y VGND VGND VPWR VPWR _4625_/A2 sky130_fd_sc_hd__buf_1
Xhold846 _7091_/Q VGND VGND VPWR VPWR _7091_/D sky130_fd_sc_hd__dlygate4sd3_1
XTAP_TAPCELL_ROW_73_1216 VGND VPWR sky130_fd_sc_hd__tapvpwrvgnd_1
Xhold857 _7063_/Q VGND VGND VPWR VPWR _7063_/D sky130_fd_sc_hd__dlygate4sd3_1
XFILLER_89_606 VGND VGND VPWR VPWR sky130_fd_sc_hd__decap_3
XFILLER_107_16 VGND VGND VPWR VPWR sky130_fd_sc_hd__decap_3
XFILLER_89_617 VGND VGND VPWR VPWR sky130_fd_sc_hd__decap_3
XFILLER_115_254 VGND VGND VPWR VPWR sky130_fd_sc_hd__decap_3
Xmax_cap576 _6678_/A VGND VGND VPWR VPWR _6662_/A sky130_fd_sc_hd__buf_2
Xhold868 _7112_/Q VGND VGND VPWR VPWR _7112_/D sky130_fd_sc_hd__dlygate4sd3_1
XFILLER_103_405 VGND VGND VPWR VPWR sky130_fd_sc_hd__fill_1
X_3466_ _7217_/Q _4307_/A2 _4532_/S _7030_/Q _3465_/X VGND VGND VPWR VPWR _3466_/X
+ sky130_fd_sc_hd__a221o_2
Xhold879 _7072_/Q VGND VGND VPWR VPWR _7072_/D sky130_fd_sc_hd__dlygate4sd3_1
XFILLER_107_49 VGND VGND VPWR VPWR sky130_fd_sc_hd__decap_3
XFILLER_88_127 VGND VGND VPWR VPWR sky130_fd_sc_hd__decap_3
X_5205_ _5205_/A _5225_/B VGND VGND VPWR VPWR _7226_/D sky130_fd_sc_hd__and2_2
XFILLER_103_449 VGND VGND VPWR VPWR sky130_fd_sc_hd__decap_3
XFILLER_69_330 VGND VGND VPWR VPWR sky130_fd_sc_hd__decap_3
XFILLER_97_650 VGND VGND VPWR VPWR sky130_fd_sc_hd__decap_3
XPHY_EDGE_ROW_95_Left_219 VGND VGND VPWR VPWR sky130_fd_sc_hd__decap_3
XTAP_TAPCELL_ROW_4_315 VGND VPWR sky130_fd_sc_hd__tapvpwrvgnd_1
XFILLER_69_363 VGND VGND VPWR VPWR sky130_fd_sc_hd__decap_3
X_5136_ _5136_/A0 _5135_/X _5140_/S VGND VGND VPWR VPWR _7251_/D sky130_fd_sc_hd__mux2_2
XFILLER_97_694 VGND VGND VPWR VPWR sky130_fd_sc_hd__decap_3
XFILLER_57_525 VGND VGND VPWR VPWR sky130_fd_sc_hd__decap_3
XFILLER_69_396 VGND VGND VPWR VPWR sky130_fd_sc_hd__decap_3
XFILLER_111_482 VGND VGND VPWR VPWR sky130_fd_sc_hd__fill_1
X_5067_ _5648_/A _5067_/B VGND VGND VPWR VPWR _5068_/C sky130_fd_sc_hd__or2_2
XFILLER_84_344 VGND VGND VPWR VPWR sky130_fd_sc_hd__decap_3
XFILLER_45_709 VGND VGND VPWR VPWR sky130_fd_sc_hd__decap_3
X_4018_ _7150_/Q _4428_/B1 _4011_/X _4017_/X VGND VGND VPWR VPWR _4018_/X sky130_fd_sc_hd__a211o_2
XFILLER_44_219 VGND VGND VPWR VPWR sky130_fd_sc_hd__fill_1
XFILLER_84_388 VGND VGND VPWR VPWR sky130_fd_sc_hd__decap_3
XFILLER_37_271 VGND VGND VPWR VPWR sky130_fd_sc_hd__decap_3
XFILLER_37_293 VGND VGND VPWR VPWR sky130_fd_sc_hd__decap_3
XFILLER_25_433 VGND VGND VPWR VPWR sky130_fd_sc_hd__decap_3
XFILLER_16_46 VGND VGND VPWR VPWR sky130_fd_sc_hd__fill_1
XTAP_TAPCELL_ROW_84_1356 VGND VPWR sky130_fd_sc_hd__tapvpwrvgnd_1
XFILLER_52_241 VGND VGND VPWR VPWR sky130_fd_sc_hd__fill_1
XFILLER_13_606 VGND VGND VPWR VPWR sky130_fd_sc_hd__decap_3
XFILLER_13_617 VGND VGND VPWR VPWR sky130_fd_sc_hd__decap_3
XFILLER_40_403 VGND VGND VPWR VPWR sky130_fd_sc_hd__decap_3
XFILLER_25_499 VGND VGND VPWR VPWR sky130_fd_sc_hd__decap_3
XTAP_TAPCELL_ROW_51_932 VGND VPWR sky130_fd_sc_hd__tapvpwrvgnd_1
XFILLER_21_650 VGND VGND VPWR VPWR sky130_fd_sc_hd__decap_3
XFILLER_21_694 VGND VGND VPWR VPWR sky130_fd_sc_hd__decap_3
XFILLER_20_171 VGND VGND VPWR VPWR sky130_fd_sc_hd__fill_1
XFILLER_107_700 VGND VGND VPWR VPWR sky130_fd_sc_hd__decap_3
XFILLER_4_304 VGND VGND VPWR VPWR sky130_fd_sc_hd__decap_3
XFILLER_4_315 VGND VGND VPWR VPWR sky130_fd_sc_hd__decap_3
XFILLER_119_582 VGND VGND VPWR VPWR sky130_fd_sc_hd__decap_3
XFILLER_106_3 VGND VGND VPWR VPWR sky130_fd_sc_hd__decap_3
XFILLER_106_243 VGND VGND VPWR VPWR sky130_fd_sc_hd__decap_3
XTAP_TAPCELL_ROW_95_1496 VGND VPWR sky130_fd_sc_hd__tapvpwrvgnd_1
XFILLER_106_265 VGND VGND VPWR VPWR sky130_fd_sc_hd__decap_3
XFILLER_122_725 VGND VGND VPWR VPWR sky130_fd_sc_hd__fill_2
XFILLER_79_116 VGND VGND VPWR VPWR sky130_fd_sc_hd__decap_3
XFILLER_106_298 VGND VGND VPWR VPWR sky130_fd_sc_hd__decap_3
XFILLER_121_235 VGND VGND VPWR VPWR sky130_fd_sc_hd__decap_3
XFILLER_95_609 VGND VGND VPWR VPWR sky130_fd_sc_hd__decap_3
XFILLER_88_672 VGND VGND VPWR VPWR sky130_fd_sc_hd__decap_3
XFILLER_0_587 VGND VGND VPWR VPWR sky130_fd_sc_hd__fill_1
XFILLER_48_547 VGND VGND VPWR VPWR sky130_fd_sc_hd__decap_3
XFILLER_75_366 VGND VGND VPWR VPWR sky130_fd_sc_hd__decap_3
XFILLER_63_517 VGND VGND VPWR VPWR sky130_fd_sc_hd__decap_3
XFILLER_75_399 VGND VGND VPWR VPWR sky130_fd_sc_hd__decap_3
XFILLER_28_271 VGND VGND VPWR VPWR sky130_fd_sc_hd__decap_3
XFILLER_90_336 VGND VGND VPWR VPWR sky130_fd_sc_hd__decap_3
XFILLER_44_731 VGND VGND VPWR VPWR sky130_fd_sc_hd__decap_3
XFILLER_113_81 VGND VGND VPWR VPWR sky130_fd_sc_hd__decap_3
XFILLER_73_30 VGND VGND VPWR VPWR sky130_fd_sc_hd__fill_2
XFILLER_90_358 VGND VGND VPWR VPWR sky130_fd_sc_hd__decap_3
XFILLER_73_52 VGND VGND VPWR VPWR sky130_fd_sc_hd__fill_1
XFILLER_71_561 VGND VGND VPWR VPWR sky130_fd_sc_hd__decap_3
XFILLER_43_252 VGND VGND VPWR VPWR sky130_fd_sc_hd__decap_3
XFILLER_43_263 VGND VGND VPWR VPWR sky130_fd_sc_hd__decap_3
XFILLER_16_477 VGND VGND VPWR VPWR sky130_fd_sc_hd__fill_1
XFILLER_31_436 VGND VGND VPWR VPWR sky130_fd_sc_hd__fill_2
XFILLER_31_447 VGND VGND VPWR VPWR sky130_fd_sc_hd__fill_1
XFILLER_31_458 VGND VGND VPWR VPWR sky130_fd_sc_hd__decap_3
XFILLER_8_610 VGND VGND VPWR VPWR sky130_fd_sc_hd__decap_3
XFILLER_12_672 VGND VGND VPWR VPWR sky130_fd_sc_hd__decap_3
XFILLER_8_643 VGND VGND VPWR VPWR sky130_fd_sc_hd__fill_1
XFILLER_8_654 VGND VGND VPWR VPWR sky130_fd_sc_hd__decap_3
XFILLER_117_508 VGND VGND VPWR VPWR sky130_fd_sc_hd__decap_3
XFILLER_8_687 VGND VGND VPWR VPWR sky130_fd_sc_hd__decap_3
XFILLER_7_175 VGND VGND VPWR VPWR sky130_fd_sc_hd__decap_3
XFILLER_113_703 VGND VGND VPWR VPWR sky130_fd_sc_hd__decap_3
X_3320_ _5647_/B VGND VGND VPWR VPWR _3326_/A sky130_fd_sc_hd__inv_2
XFILLER_98_414 VGND VGND VPWR VPWR sky130_fd_sc_hd__decap_3
XFILLER_98_82 VGND VGND VPWR VPWR sky130_fd_sc_hd__fill_2
XFILLER_98_436 VGND VGND VPWR VPWR sky130_fd_sc_hd__decap_3
XFILLER_98_469 VGND VGND VPWR VPWR sky130_fd_sc_hd__decap_3
XFILLER_79_650 VGND VGND VPWR VPWR sky130_fd_sc_hd__decap_3
XFILLER_112_268 VGND VGND VPWR VPWR sky130_fd_sc_hd__decap_3
XFILLER_39_503 VGND VGND VPWR VPWR sky130_fd_sc_hd__fill_1
XFILLER_79_694 VGND VGND VPWR VPWR sky130_fd_sc_hd__decap_3
XFILLER_94_631 VGND VGND VPWR VPWR sky130_fd_sc_hd__decap_3
XFILLER_27_709 VGND VGND VPWR VPWR sky130_fd_sc_hd__decap_3
XFILLER_94_675 VGND VGND VPWR VPWR sky130_fd_sc_hd__decap_3
XFILLER_66_377 VGND VGND VPWR VPWR sky130_fd_sc_hd__fill_1
XFILLER_26_208 VGND VGND VPWR VPWR sky130_fd_sc_hd__decap_3
X_6941_ _7403_/CLK _6941_/D VGND VGND VPWR VPWR _6941_/Q sky130_fd_sc_hd__dfxtp_2
XFILLER_66_399 VGND VGND VPWR VPWR sky130_fd_sc_hd__decap_3
XFILLER_19_260 VGND VGND VPWR VPWR sky130_fd_sc_hd__fill_1
XTAP_TAPCELL_ROW_37_748 VGND VPWR sky130_fd_sc_hd__tapvpwrvgnd_1
X_6872_ _7380_/CLK _6872_/D VGND VGND VPWR VPWR _6872_/Q sky130_fd_sc_hd__dfxtp_2
XFILLER_50_701 VGND VGND VPWR VPWR sky130_fd_sc_hd__decap_3
XFILLER_34_274 VGND VGND VPWR VPWR sky130_fd_sc_hd__decap_3
XFILLER_50_734 VGND VGND VPWR VPWR sky130_fd_sc_hd__fill_1
XFILLER_34_285 VGND VGND VPWR VPWR sky130_fd_sc_hd__decap_3
XTAP_TAPCELL_ROW_17_483 VGND VPWR sky130_fd_sc_hd__tapvpwrvgnd_1
XFILLER_22_436 VGND VGND VPWR VPWR sky130_fd_sc_hd__fill_1
XTAP_TAPCELL_ROW_17_494 VGND VPWR sky130_fd_sc_hd__tapvpwrvgnd_1
XFILLER_22_458 VGND VGND VPWR VPWR sky130_fd_sc_hd__decap_3
X_4705_ _6995_/Q _6996_/Q _4963_/A VGND VGND VPWR VPWR _4931_/A sky130_fd_sc_hd__and3_2
X_4636_ _4186_/A _4636_/B VGND VGND VPWR VPWR _4639_/A sky130_fd_sc_hd__and2b_2
XFILLER_118_15 VGND VGND VPWR VPWR sky130_fd_sc_hd__decap_3
Xhold610 _6895_/Q VGND VGND VPWR VPWR _6895_/D sky130_fd_sc_hd__dlygate4sd3_1
XFILLER_116_530 VGND VGND VPWR VPWR sky130_fd_sc_hd__fill_2
Xhold621 _6971_/Q VGND VGND VPWR VPWR _6971_/D sky130_fd_sc_hd__dlygate4sd3_1
X_7355_ _7355_/CLK _7355_/D _6635_/Y VGND VGND VPWR VPWR _7355_/Q sky130_fd_sc_hd__dfrtp_2
X_4567_ _7297_/Q _4577_/B VGND VGND VPWR VPWR _7297_/D sky130_fd_sc_hd__and2_2
XFILLER_118_59 VGND VGND VPWR VPWR sky130_fd_sc_hd__decap_3
Xhold632 _6857_/Q VGND VGND VPWR VPWR _6857_/D sky130_fd_sc_hd__dlygate4sd3_1
Xhold643 _6921_/Q VGND VGND VPWR VPWR _6921_/D sky130_fd_sc_hd__dlygate4sd3_1
XFILLER_116_563 VGND VGND VPWR VPWR sky130_fd_sc_hd__decap_3
X_6306_ _6651_/A VGND VGND VPWR VPWR _6306_/Y sky130_fd_sc_hd__inv_2
Xhold654 _6759_/Q VGND VGND VPWR VPWR _6759_/D sky130_fd_sc_hd__dlygate4sd3_1
Xhold665 _6869_/Q VGND VGND VPWR VPWR _6869_/D sky130_fd_sc_hd__dlygate4sd3_1
XFILLER_104_725 VGND VGND VPWR VPWR sky130_fd_sc_hd__decap_3
Xhold676 _6943_/Q VGND VGND VPWR VPWR _6943_/D sky130_fd_sc_hd__dlygate4sd3_1
X_7286_ _7318_/CLK _7286_/D _6566_/Y VGND VGND VPWR VPWR _7286_/Q sky130_fd_sc_hd__dfrtp_2
XFILLER_89_436 VGND VGND VPWR VPWR sky130_fd_sc_hd__decap_3
Xhold687 _6824_/Q VGND VGND VPWR VPWR _6824_/D sky130_fd_sc_hd__dlygate4sd3_1
Xhold698 _6723_/Q VGND VGND VPWR VPWR _6723_/D sky130_fd_sc_hd__dlygate4sd3_1
XFILLER_89_458 VGND VGND VPWR VPWR sky130_fd_sc_hd__decap_3
XFILLER_77_609 VGND VGND VPWR VPWR sky130_fd_sc_hd__decap_3
X_3449_ _3449_/A _3449_/B _3449_/C VGND VGND VPWR VPWR _4337_/B sky130_fd_sc_hd__and3_2
XFILLER_57_300 VGND VGND VPWR VPWR sky130_fd_sc_hd__decap_3
XFILLER_97_480 VGND VGND VPWR VPWR sky130_fd_sc_hd__decap_3
XFILLER_85_620 VGND VGND VPWR VPWR sky130_fd_sc_hd__decap_3
XFILLER_94_29 VGND VGND VPWR VPWR sky130_fd_sc_hd__decap_3
XFILLER_69_193 VGND VGND VPWR VPWR sky130_fd_sc_hd__fill_2
X_5119_ _5670_/A _5670_/B _6984_/Q VGND VGND VPWR VPWR _5120_/B sky130_fd_sc_hd__a21oi_2
XFILLER_85_653 VGND VGND VPWR VPWR sky130_fd_sc_hd__decap_3
XFILLER_111_290 VGND VGND VPWR VPWR sky130_fd_sc_hd__decap_3
XFILLER_84_141 VGND VGND VPWR VPWR sky130_fd_sc_hd__decap_3
XFILLER_57_355 VGND VGND VPWR VPWR sky130_fd_sc_hd__decap_3
XFILLER_85_697 VGND VGND VPWR VPWR sky130_fd_sc_hd__decap_3
XFILLER_72_325 VGND VGND VPWR VPWR sky130_fd_sc_hd__fill_2
XFILLER_26_731 VGND VGND VPWR VPWR sky130_fd_sc_hd__decap_3
XFILLER_25_230 VGND VGND VPWR VPWR sky130_fd_sc_hd__decap_3
XFILLER_53_561 VGND VGND VPWR VPWR sky130_fd_sc_hd__fill_1
XFILLER_41_712 VGND VGND VPWR VPWR sky130_fd_sc_hd__decap_3
XFILLER_13_425 VGND VGND VPWR VPWR sky130_fd_sc_hd__fill_2
XFILLER_13_436 VGND VGND VPWR VPWR sky130_fd_sc_hd__decap_3
XFILLER_40_244 VGND VGND VPWR VPWR sky130_fd_sc_hd__fill_2
XFILLER_40_266 VGND VGND VPWR VPWR sky130_fd_sc_hd__decap_3
XTAP_TAPCELL_ROW_97_1525 VGND VPWR sky130_fd_sc_hd__tapvpwrvgnd_1
XFILLER_5_635 VGND VGND VPWR VPWR sky130_fd_sc_hd__decap_3
XFILLER_119_390 VGND VGND VPWR VPWR sky130_fd_sc_hd__fill_2
XFILLER_107_541 VGND VGND VPWR VPWR sky130_fd_sc_hd__decap_3
XFILLER_5_668 VGND VGND VPWR VPWR sky130_fd_sc_hd__decap_3
XFILLER_5_679 VGND VGND VPWR VPWR sky130_fd_sc_hd__decap_3
XFILLER_107_585 VGND VGND VPWR VPWR sky130_fd_sc_hd__decap_3
XFILLER_122_522 VGND VGND VPWR VPWR sky130_fd_sc_hd__decap_3
XFILLER_122_533 VGND VGND VPWR VPWR sky130_fd_sc_hd__decap_3
XFILLER_68_41 VGND VGND VPWR VPWR sky130_fd_sc_hd__decap_3
XFILLER_122_566 VGND VGND VPWR VPWR sky130_fd_sc_hd__decap_3
XFILLER_95_417 VGND VGND VPWR VPWR sky130_fd_sc_hd__decap_3
XFILLER_110_728 VGND VGND VPWR VPWR sky130_fd_sc_hd__decap_3
XFILLER_0_362 VGND VGND VPWR VPWR sky130_fd_sc_hd__fill_2
XFILLER_68_85 VGND VGND VPWR VPWR sky130_fd_sc_hd__fill_1
XFILLER_48_300 VGND VGND VPWR VPWR sky130_fd_sc_hd__decap_3
XFILLER_76_631 VGND VGND VPWR VPWR sky130_fd_sc_hd__decap_3
XFILLER_48_333 VGND VGND VPWR VPWR sky130_fd_sc_hd__decap_3
XFILLER_76_675 VGND VGND VPWR VPWR sky130_fd_sc_hd__decap_3
XFILLER_91_612 VGND VGND VPWR VPWR sky130_fd_sc_hd__decap_3
XFILLER_91_623 VGND VGND VPWR VPWR sky130_fd_sc_hd__decap_3
XFILLER_63_314 VGND VGND VPWR VPWR sky130_fd_sc_hd__fill_1
XFILLER_84_62 VGND VGND VPWR VPWR sky130_fd_sc_hd__decap_3
XFILLER_90_111 VGND VGND VPWR VPWR sky130_fd_sc_hd__decap_3
XFILLER_29_580 VGND VGND VPWR VPWR sky130_fd_sc_hd__decap_3
Xplace303 _3893_/A2 VGND VGND VPWR VPWR _3891_/A2 sky130_fd_sc_hd__buf_2
XFILLER_75_196 VGND VGND VPWR VPWR sky130_fd_sc_hd__decap_3
Xplace314 _3586_/Y VGND VGND VPWR VPWR _3600_/A sky130_fd_sc_hd__buf_2
XFILLER_91_656 VGND VGND VPWR VPWR sky130_fd_sc_hd__decap_3
Xplace325 _4422_/A2 VGND VGND VPWR VPWR _4437_/A2 sky130_fd_sc_hd__buf_2
XFILLER_90_144 VGND VGND VPWR VPWR sky130_fd_sc_hd__decap_3
XFILLER_63_358 VGND VGND VPWR VPWR sky130_fd_sc_hd__decap_3
XTAP_TAPCELL_ROW_106_1643 VGND VPWR sky130_fd_sc_hd__tapvpwrvgnd_1
Xplace336 _4267_/A2 VGND VGND VPWR VPWR _4434_/B1 sky130_fd_sc_hd__buf_2
XFILLER_16_230 VGND VGND VPWR VPWR sky130_fd_sc_hd__decap_3
XTAP_TAPCELL_ROW_34_707 VGND VPWR sky130_fd_sc_hd__tapvpwrvgnd_1
XFILLER_44_550 VGND VGND VPWR VPWR sky130_fd_sc_hd__decap_3
Xplace347 _5072_/A VGND VGND VPWR VPWR _4970_/A1 sky130_fd_sc_hd__buf_2
XFILLER_32_701 VGND VGND VPWR VPWR sky130_fd_sc_hd__decap_3
Xplace358 _4979_/S VGND VGND VPWR VPWR _4914_/S sky130_fd_sc_hd__buf_2
Xplace369 _4347_/C1 VGND VGND VPWR VPWR _4429_/C1 sky130_fd_sc_hd__buf_2
XFILLER_90_188 VGND VGND VPWR VPWR sky130_fd_sc_hd__decap_3
XFILLER_32_734 VGND VGND VPWR VPWR sky130_fd_sc_hd__fill_1
XFILLER_16_296 VGND VGND VPWR VPWR sky130_fd_sc_hd__decap_3
XTAP_TAPCELL_ROW_14_453 VGND VPWR sky130_fd_sc_hd__tapvpwrvgnd_1
XFILLER_31_266 VGND VGND VPWR VPWR sky130_fd_sc_hd__decap_3
XFILLER_12_480 VGND VGND VPWR VPWR sky130_fd_sc_hd__decap_3
XFILLER_8_473 VGND VGND VPWR VPWR sky130_fd_sc_hd__decap_3
XFILLER_69_3 VGND VGND VPWR VPWR sky130_fd_sc_hd__decap_3
XTAP_TAPCELL_ROW_57_1008 VGND VPWR sky130_fd_sc_hd__tapvpwrvgnd_1
X_4421_ _7240_/Q _4421_/A2 _4430_/B1 _7176_/Q _4420_/X VGND VGND VPWR VPWR _4421_/X
+ sky130_fd_sc_hd__a221o_2
XFILLER_99_712 VGND VGND VPWR VPWR sky130_fd_sc_hd__decap_3
XTAP_TAPCELL_ROW_117_1783 VGND VPWR sky130_fd_sc_hd__tapvpwrvgnd_1
XTAP_TAPCELL_ROW_117_1794 VGND VPWR sky130_fd_sc_hd__tapvpwrvgnd_1
X_7140_ _7360_/CLK _7140_/D _6420_/Y VGND VGND VPWR VPWR _7140_/Q sky130_fd_sc_hd__dfrtp_2
XFILLER_113_500 VGND VGND VPWR VPWR sky130_fd_sc_hd__decap_3
X_4352_ _7289_/Q _5080_/S _4352_/B1 _7161_/Q _4351_/X VGND VGND VPWR VPWR _4352_/X
+ sky130_fd_sc_hd__a221o_2
XFILLER_113_511 VGND VGND VPWR VPWR sky130_fd_sc_hd__decap_3
XFILLER_4_690 VGND VGND VPWR VPWR sky130_fd_sc_hd__decap_3
X_3303_ _4467_/A _3519_/B _3302_/X VGND VGND VPWR VPWR _6981_/D sky130_fd_sc_hd__o21a_4
XFILLER_113_544 VGND VGND VPWR VPWR sky130_fd_sc_hd__decap_3
X_4283_ _7094_/Q _4335_/B1 _4351_/B1 _7126_/Q VGND VGND VPWR VPWR _4283_/X sky130_fd_sc_hd__a22o_2
X_7071_ _7401_/CLK _7071_/D _6351_/Y VGND VGND VPWR VPWR _7071_/Q sky130_fd_sc_hd__dfrtp_2
XFILLER_59_609 VGND VGND VPWR VPWR sky130_fd_sc_hd__decap_3
XFILLER_101_706 VGND VGND VPWR VPWR sky130_fd_sc_hd__decap_3
XFILLER_113_588 VGND VGND VPWR VPWR sky130_fd_sc_hd__decap_3
XFILLER_86_439 VGND VGND VPWR VPWR sky130_fd_sc_hd__decap_3
XFILLER_67_620 VGND VGND VPWR VPWR sky130_fd_sc_hd__decap_3
XFILLER_100_227 VGND VGND VPWR VPWR sky130_fd_sc_hd__decap_3
XFILLER_67_653 VGND VGND VPWR VPWR sky130_fd_sc_hd__decap_3
XFILLER_104_17 VGND VGND VPWR VPWR sky130_fd_sc_hd__decap_3
XFILLER_82_601 VGND VGND VPWR VPWR sky130_fd_sc_hd__decap_3
XFILLER_39_366 VGND VGND VPWR VPWR sky130_fd_sc_hd__decap_3
XFILLER_27_517 VGND VGND VPWR VPWR sky130_fd_sc_hd__decap_3
XFILLER_67_697 VGND VGND VPWR VPWR sky130_fd_sc_hd__decap_3
XFILLER_39_388 VGND VGND VPWR VPWR sky130_fd_sc_hd__decap_3
XFILLER_39_399 VGND VGND VPWR VPWR sky130_fd_sc_hd__fill_2
XFILLER_82_634 VGND VGND VPWR VPWR sky130_fd_sc_hd__decap_3
XFILLER_82_645 VGND VGND VPWR VPWR sky130_fd_sc_hd__decap_3
XFILLER_54_336 VGND VGND VPWR VPWR sky130_fd_sc_hd__decap_3
XTAP_TAPCELL_ROW_68_1148 VGND VPWR sky130_fd_sc_hd__tapvpwrvgnd_1
X_6924_ _7386_/CLK _6924_/D VGND VGND VPWR VPWR _6924_/Q sky130_fd_sc_hd__dfxtp_2
XFILLER_82_678 VGND VGND VPWR VPWR sky130_fd_sc_hd__decap_3
XFILLER_81_166 VGND VGND VPWR VPWR sky130_fd_sc_hd__fill_2
XFILLER_23_712 VGND VGND VPWR VPWR sky130_fd_sc_hd__decap_3
XTAP_TAPCELL_ROW_81_1315 VGND VPWR sky130_fd_sc_hd__tapvpwrvgnd_1
XFILLER_120_38 VGND VGND VPWR VPWR sky130_fd_sc_hd__decap_3
XTAP_TAPCELL_ROW_81_1326 VGND VPWR sky130_fd_sc_hd__tapvpwrvgnd_1
X_6855_ clkload8/A _6855_/D VGND VGND VPWR VPWR _6855_/Q sky130_fd_sc_hd__dfxtp_2
XFILLER_62_380 VGND VGND VPWR VPWR sky130_fd_sc_hd__decap_3
XFILLER_35_594 VGND VGND VPWR VPWR sky130_fd_sc_hd__decap_3
Xfanout26 _6626_/A VGND VGND VPWR VPWR _6632_/A sky130_fd_sc_hd__buf_2
XFILLER_22_222 VGND VGND VPWR VPWR sky130_fd_sc_hd__decap_3
Xfanout37 fanout47/X VGND VGND VPWR VPWR _6544_/A sky130_fd_sc_hd__buf_2
Xfanout48 _6686_/A VGND VGND VPWR VPWR _6674_/A sky130_fd_sc_hd__buf_2
XFILLER_22_244 VGND VGND VPWR VPWR sky130_fd_sc_hd__decap_3
Xfanout59 _6581_/A VGND VGND VPWR VPWR _6610_/A sky130_fd_sc_hd__buf_2
X_6786_ _7378_/CLK _6786_/D VGND VGND VPWR VPWR _6786_/Q sky130_fd_sc_hd__dfxtp_2
XFILLER_22_277 VGND VGND VPWR VPWR sky130_fd_sc_hd__decap_3
XFILLER_13_36 VGND VGND VPWR VPWR sky130_fd_sc_hd__fill_1
X_5737_ _7374_/Q hold907/X _5737_/S VGND VGND VPWR VPWR _6718_/D sky130_fd_sc_hd__mux2_2
XFILLER_108_316 VGND VGND VPWR VPWR sky130_fd_sc_hd__fill_2
X_5668_ _5668_/A _5668_/B VGND VGND VPWR VPWR _6980_/D sky130_fd_sc_hd__or2_2
X_4619_ _5086_/A _4619_/B _5101_/B _5073_/A VGND VGND VPWR VPWR _4619_/Y sky130_fd_sc_hd__nor4_2
XTAP_TAPCELL_ROW_79_1288 VGND VPWR sky130_fd_sc_hd__tapvpwrvgnd_1
XTAP_TAPCELL_ROW_79_1299 VGND VPWR sky130_fd_sc_hd__tapvpwrvgnd_1
X_7338_ _7374_/CLK _7338_/D _6618_/Y VGND VGND VPWR VPWR _7338_/Q sky130_fd_sc_hd__dfrtp_2
XFILLER_2_638 VGND VGND VPWR VPWR sky130_fd_sc_hd__decap_3
XFILLER_89_222 VGND VGND VPWR VPWR sky130_fd_sc_hd__fill_2
XTAP_TAPCELL_ROW_92_1466 VGND VPWR sky130_fd_sc_hd__tapvpwrvgnd_1
X_7269_ _7368_/CLK _7269_/D _6549_/Y VGND VGND VPWR VPWR _7269_/Q sky130_fd_sc_hd__dfrtp_2
XFILLER_89_255 VGND VGND VPWR VPWR sky130_fd_sc_hd__decap_3
XFILLER_104_566 VGND VGND VPWR VPWR sky130_fd_sc_hd__decap_3
XFILLER_38_11 VGND VGND VPWR VPWR sky130_fd_sc_hd__decap_3
XFILLER_89_299 VGND VGND VPWR VPWR sky130_fd_sc_hd__decap_3
XFILLER_58_620 VGND VGND VPWR VPWR sky130_fd_sc_hd__decap_3
XFILLER_38_22 VGND VGND VPWR VPWR sky130_fd_sc_hd__decap_3
Xhold1140 _7286_/Q VGND VGND VPWR VPWR _4589_/A sky130_fd_sc_hd__dlygate4sd3_1
XFILLER_58_675 VGND VGND VPWR VPWR sky130_fd_sc_hd__decap_3
Xhold1151 _7130_/Q VGND VGND VPWR VPWR _5407_/A0 sky130_fd_sc_hd__dlygate4sd3_1
Xhold1162 _7293_/Q VGND VGND VPWR VPWR _4575_/A sky130_fd_sc_hd__dlygate4sd3_1
XFILLER_38_99 VGND VGND VPWR VPWR sky130_fd_sc_hd__decap_3
Xhold1173 _7179_/Q VGND VGND VPWR VPWR _5302_/A0 sky130_fd_sc_hd__dlygate4sd3_1
XFILLER_85_483 VGND VGND VPWR VPWR sky130_fd_sc_hd__decap_3
XFILLER_73_623 VGND VGND VPWR VPWR sky130_fd_sc_hd__decap_3
XFILLER_72_100 VGND VGND VPWR VPWR sky130_fd_sc_hd__decap_3
XFILLER_45_314 VGND VGND VPWR VPWR sky130_fd_sc_hd__decap_3
XFILLER_57_185 VGND VGND VPWR VPWR sky130_fd_sc_hd__decap_3
Xhold1184 _7188_/Q VGND VGND VPWR VPWR _5283_/B2 sky130_fd_sc_hd__dlygate4sd3_1
Xhold1195 _7229_/Q VGND VGND VPWR VPWR _5198_/A sky130_fd_sc_hd__dlygate4sd3_1
XFILLER_73_656 VGND VGND VPWR VPWR sky130_fd_sc_hd__decap_3
XFILLER_72_144 VGND VGND VPWR VPWR sky130_fd_sc_hd__decap_3
XFILLER_45_358 VGND VGND VPWR VPWR sky130_fd_sc_hd__decap_3
XFILLER_54_32 VGND VGND VPWR VPWR sky130_fd_sc_hd__decap_3
XFILLER_14_701 VGND VGND VPWR VPWR sky130_fd_sc_hd__decap_3
XFILLER_60_317 VGND VGND VPWR VPWR sky130_fd_sc_hd__decap_3
XFILLER_54_54 VGND VGND VPWR VPWR sky130_fd_sc_hd__decap_3
XFILLER_72_177 VGND VGND VPWR VPWR sky130_fd_sc_hd__decap_3
XFILLER_26_583 VGND VGND VPWR VPWR sky130_fd_sc_hd__decap_3
XFILLER_14_734 VGND VGND VPWR VPWR sky130_fd_sc_hd__fill_1
XFILLER_13_211 VGND VGND VPWR VPWR sky130_fd_sc_hd__fill_1
XFILLER_41_564 VGND VGND VPWR VPWR sky130_fd_sc_hd__fill_1
XFILLER_13_255 VGND VGND VPWR VPWR sky130_fd_sc_hd__decap_3
XFILLER_41_586 VGND VGND VPWR VPWR sky130_fd_sc_hd__decap_3
XFILLER_9_248 VGND VGND VPWR VPWR sky130_fd_sc_hd__decap_3
XTAP_TAPCELL_ROW_11_412 VGND VPWR sky130_fd_sc_hd__tapvpwrvgnd_1
XFILLER_13_299 VGND VGND VPWR VPWR sky130_fd_sc_hd__decap_3
XTAP_TAPCELL_ROW_101_1584 VGND VPWR sky130_fd_sc_hd__tapvpwrvgnd_1
Xclkload18 _7354_/CLK VGND VGND VPWR VPWR clkload18/X sky130_fd_sc_hd__clkbuf_1
Xclkload29 _7365_/CLK VGND VGND VPWR VPWR clkload29/Y sky130_fd_sc_hd__clkinv_2
XFILLER_55_9 VGND VGND VPWR VPWR sky130_fd_sc_hd__fill_1
XFILLER_107_393 VGND VGND VPWR VPWR sky130_fd_sc_hd__decap_3
XFILLER_79_84 VGND VGND VPWR VPWR sky130_fd_sc_hd__decap_3
XFILLER_96_704 VGND VGND VPWR VPWR sky130_fd_sc_hd__decap_3
XFILLER_122_341 VGND VGND VPWR VPWR sky130_fd_sc_hd__fill_1
XFILLER_1_671 VGND VGND VPWR VPWR sky130_fd_sc_hd__fill_1
XFILLER_95_225 VGND VGND VPWR VPWR sky130_fd_sc_hd__decap_3
XFILLER_49_620 VGND VGND VPWR VPWR sky130_fd_sc_hd__decap_3
XFILLER_1_682 VGND VGND VPWR VPWR sky130_fd_sc_hd__decap_3
XFILLER_110_536 VGND VGND VPWR VPWR sky130_fd_sc_hd__decap_3
XFILLER_49_653 VGND VGND VPWR VPWR sky130_fd_sc_hd__decap_3
XFILLER_110_569 VGND VGND VPWR VPWR sky130_fd_sc_hd__decap_3
XFILLER_95_269 VGND VGND VPWR VPWR sky130_fd_sc_hd__fill_2
XFILLER_95_72 VGND VGND VPWR VPWR sky130_fd_sc_hd__decap_3
XFILLER_48_141 VGND VGND VPWR VPWR sky130_fd_sc_hd__decap_3
XFILLER_64_601 VGND VGND VPWR VPWR sky130_fd_sc_hd__decap_3
XFILLER_49_697 VGND VGND VPWR VPWR sky130_fd_sc_hd__decap_3
XTAP_TAPCELL_ROW_19_512 VGND VPWR sky130_fd_sc_hd__tapvpwrvgnd_1
XFILLER_64_634 VGND VGND VPWR VPWR sky130_fd_sc_hd__decap_3
XFILLER_91_420 VGND VGND VPWR VPWR sky130_fd_sc_hd__decap_3
XFILLER_64_645 VGND VGND VPWR VPWR sky130_fd_sc_hd__decap_3
XFILLER_36_336 VGND VGND VPWR VPWR sky130_fd_sc_hd__decap_3
XFILLER_63_122 VGND VGND VPWR VPWR sky130_fd_sc_hd__fill_1
XFILLER_91_464 VGND VGND VPWR VPWR sky130_fd_sc_hd__decap_3
XFILLER_64_678 VGND VGND VPWR VPWR sky130_fd_sc_hd__decap_3
XTAP_TAPCELL_ROW_47_876 VGND VPWR sky130_fd_sc_hd__tapvpwrvgnd_1
X_4970_ _4970_/A1 _4950_/B _4967_/B _5033_/B2 VGND VGND VPWR VPWR _4970_/X sky130_fd_sc_hd__a22o_2
XFILLER_17_561 VGND VGND VPWR VPWR sky130_fd_sc_hd__decap_3
XFILLER_51_317 VGND VGND VPWR VPWR sky130_fd_sc_hd__decap_3
X_3921_ _6914_/Q _3926_/A2 _5660_/B _6688_/Q VGND VGND VPWR VPWR _3921_/X sky130_fd_sc_hd__a22o_2
XFILLER_63_199 VGND VGND VPWR VPWR sky130_fd_sc_hd__decap_3
XFILLER_17_594 VGND VGND VPWR VPWR sky130_fd_sc_hd__decap_3
X_6640_ _6640_/A VGND VGND VPWR VPWR _6640_/Y sky130_fd_sc_hd__inv_2
XFILLER_20_704 VGND VGND VPWR VPWR sky130_fd_sc_hd__decap_3
X_3852_ _6748_/Q _3892_/A2 _3892_/B1 _6742_/Q VGND VGND VPWR VPWR _3852_/X sky130_fd_sc_hd__a22o_2
XFILLER_32_586 VGND VGND VPWR VPWR sky130_fd_sc_hd__fill_2
XTAP_TAPCELL_ROW_63_1089 VGND VPWR sky130_fd_sc_hd__tapvpwrvgnd_1
X_6571_ _6603_/A VGND VGND VPWR VPWR _6571_/Y sky130_fd_sc_hd__inv_2
XTAP_TAPCELL_ROW_119_1812 VGND VPWR sky130_fd_sc_hd__tapvpwrvgnd_1
X_3783_ _6812_/Q _3893_/B1 _3850_/B1 _6822_/Q _3782_/X VGND VGND VPWR VPWR _3783_/X
+ sky130_fd_sc_hd__a221o_2
XFILLER_118_625 VGND VGND VPWR VPWR sky130_fd_sc_hd__decap_3
XFILLER_117_102 VGND VGND VPWR VPWR sky130_fd_sc_hd__decap_3
XFILLER_118_669 VGND VGND VPWR VPWR sky130_fd_sc_hd__decap_3
Xoutput501 _5161_/A VGND VGND VPWR VPWR instruction_out[18] sky130_fd_sc_hd__clkdlybuf4s25_1
Xoutput512 _7412_/X VGND VGND VPWR VPWR instruction_out[30] sky130_fd_sc_hd__clkdlybuf4s25_1
X_4404_ _7306_/Q _4914_/S _4434_/A2 _7114_/Q VGND VGND VPWR VPWR _4404_/X sky130_fd_sc_hd__a22o_2
Xoutput523 _6989_/Q VGND VGND VPWR VPWR pc_out[12] sky130_fd_sc_hd__clkdlybuf4s25_1
Xoutput534 _6999_/Q VGND VGND VPWR VPWR pc_out[22] sky130_fd_sc_hd__clkdlybuf4s25_1
Xoutput545 _3331_/A VGND VGND VPWR VPWR pc_out[3] sky130_fd_sc_hd__clkdlybuf4s25_1
X_7123_ _7352_/CLK _7123_/D _6403_/Y VGND VGND VPWR VPWR _7123_/Q sky130_fd_sc_hd__dfrtp_2
XFILLER_99_553 VGND VGND VPWR VPWR sky130_fd_sc_hd__decap_3
X_4335_ _7287_/Q _5080_/S _4335_/B1 _7095_/Q VGND VGND VPWR VPWR _4336_/C sky130_fd_sc_hd__a22o_2
XFILLER_99_564 VGND VGND VPWR VPWR sky130_fd_sc_hd__decap_3
XFILLER_87_715 VGND VGND VPWR VPWR sky130_fd_sc_hd__decap_3
XFILLER_59_417 VGND VGND VPWR VPWR sky130_fd_sc_hd__decap_3
XFILLER_115_16 VGND VGND VPWR VPWR sky130_fd_sc_hd__decap_3
XFILLER_99_597 VGND VGND VPWR VPWR sky130_fd_sc_hd__decap_3
XFILLER_113_374 VGND VGND VPWR VPWR sky130_fd_sc_hd__decap_3
X_7054_ _7370_/CLK _7054_/D _6334_/Y VGND VGND VPWR VPWR _7054_/Q sky130_fd_sc_hd__dfrtp_2
XFILLER_59_439 VGND VGND VPWR VPWR sky130_fd_sc_hd__decap_3
X_4266_ _7294_/Q _5080_/S _4335_/B1 _7102_/Q VGND VGND VPWR VPWR _4271_/A sky130_fd_sc_hd__a22o_2
XFILLER_115_49 VGND VGND VPWR VPWR sky130_fd_sc_hd__decap_3
XFILLER_113_396 VGND VGND VPWR VPWR sky130_fd_sc_hd__decap_3
XFILLER_86_236 VGND VGND VPWR VPWR sky130_fd_sc_hd__decap_3
XFILLER_101_558 VGND VGND VPWR VPWR sky130_fd_sc_hd__fill_2
X_4197_ _7199_/Q _3966_/S _4429_/A2 _7044_/Q _4196_/X VGND VGND VPWR VPWR _4197_/X
+ sky130_fd_sc_hd__a221o_2
XFILLER_55_612 VGND VGND VPWR VPWR sky130_fd_sc_hd__decap_3
XFILLER_55_623 VGND VGND VPWR VPWR sky130_fd_sc_hd__decap_3
XFILLER_27_314 VGND VGND VPWR VPWR sky130_fd_sc_hd__decap_3
XFILLER_67_494 VGND VGND VPWR VPWR sky130_fd_sc_hd__decap_3
XFILLER_39_185 VGND VGND VPWR VPWR sky130_fd_sc_hd__decap_3
XFILLER_94_291 VGND VGND VPWR VPWR sky130_fd_sc_hd__decap_3
XFILLER_82_442 VGND VGND VPWR VPWR sky130_fd_sc_hd__fill_2
XFILLER_55_656 VGND VGND VPWR VPWR sky130_fd_sc_hd__decap_3
XFILLER_70_604 VGND VGND VPWR VPWR sky130_fd_sc_hd__decap_3
XFILLER_82_475 VGND VGND VPWR VPWR sky130_fd_sc_hd__fill_1
XFILLER_54_166 VGND VGND VPWR VPWR sky130_fd_sc_hd__decap_3
XFILLER_82_486 VGND VGND VPWR VPWR sky130_fd_sc_hd__decap_3
XFILLER_42_317 VGND VGND VPWR VPWR sky130_fd_sc_hd__decap_3
XFILLER_70_637 VGND VGND VPWR VPWR sky130_fd_sc_hd__decap_3
X_6907_ clkload5/A _6907_/D VGND VGND VPWR VPWR _6907_/Q sky130_fd_sc_hd__dfxtp_2
XFILLER_70_648 VGND VGND VPWR VPWR sky130_fd_sc_hd__decap_3
XFILLER_42_339 VGND VGND VPWR VPWR sky130_fd_sc_hd__fill_1
XFILLER_24_13 VGND VGND VPWR VPWR sky130_fd_sc_hd__decap_3
XFILLER_23_553 VGND VGND VPWR VPWR sky130_fd_sc_hd__decap_3
X_6838_ _6978_/CLK _6838_/D VGND VGND VPWR VPWR _6838_/Q sky130_fd_sc_hd__dfxtp_2
XFILLER_11_715 VGND VGND VPWR VPWR sky130_fd_sc_hd__decap_3
XFILLER_23_586 VGND VGND VPWR VPWR sky130_fd_sc_hd__decap_3
X_6769_ clkload9/A _6769_/D VGND VGND VPWR VPWR _6769_/Q sky130_fd_sc_hd__dfxtp_2
XFILLER_109_603 VGND VGND VPWR VPWR sky130_fd_sc_hd__decap_3
XFILLER_6_218 VGND VGND VPWR VPWR sky130_fd_sc_hd__fill_1
XFILLER_108_113 VGND VGND VPWR VPWR sky130_fd_sc_hd__decap_3
XFILLER_109_647 VGND VGND VPWR VPWR sky130_fd_sc_hd__decap_3
XFILLER_123_116 VGND VGND VPWR VPWR sky130_fd_sc_hd__fill_1
XFILLER_2_424 VGND VGND VPWR VPWR sky130_fd_sc_hd__decap_3
XFILLER_117_691 VGND VGND VPWR VPWR sky130_fd_sc_hd__decap_3
XFILLER_116_190 VGND VGND VPWR VPWR sky130_fd_sc_hd__decap_3
XFILLER_78_704 VGND VGND VPWR VPWR sky130_fd_sc_hd__decap_3
XFILLER_104_341 VGND VGND VPWR VPWR sky130_fd_sc_hd__decap_3
XFILLER_104_363 VGND VGND VPWR VPWR sky130_fd_sc_hd__fill_1
XFILLER_77_214 VGND VGND VPWR VPWR sky130_fd_sc_hd__decap_3
XFILLER_104_374 VGND VGND VPWR VPWR sky130_fd_sc_hd__decap_3
XFILLER_49_65 VGND VGND VPWR VPWR sky130_fd_sc_hd__decap_3
XFILLER_77_225 VGND VGND VPWR VPWR sky130_fd_sc_hd__decap_3
XFILLER_77_236 VGND VGND VPWR VPWR sky130_fd_sc_hd__decap_3
XFILLER_93_718 VGND VGND VPWR VPWR sky130_fd_sc_hd__decap_3
XFILLER_58_450 VGND VGND VPWR VPWR sky130_fd_sc_hd__decap_3
XFILLER_93_729 VGND VGND VPWR VPWR sky130_fd_sc_hd__decap_3
XFILLER_65_31 VGND VGND VPWR VPWR sky130_fd_sc_hd__decap_3
XFILLER_46_623 VGND VGND VPWR VPWR sky130_fd_sc_hd__decap_3
XFILLER_45_111 VGND VGND VPWR VPWR sky130_fd_sc_hd__fill_1
XFILLER_100_580 VGND VGND VPWR VPWR sky130_fd_sc_hd__decap_3
XFILLER_46_645 VGND VGND VPWR VPWR sky130_fd_sc_hd__decap_3
XFILLER_18_336 VGND VGND VPWR VPWR sky130_fd_sc_hd__decap_3
XFILLER_18_358 VGND VGND VPWR VPWR sky130_fd_sc_hd__decap_3
XFILLER_46_678 VGND VGND VPWR VPWR sky130_fd_sc_hd__decap_3
XFILLER_61_626 VGND VGND VPWR VPWR sky130_fd_sc_hd__decap_3
XTAP_TAPCELL_ROW_103_1602 VGND VPWR sky130_fd_sc_hd__tapvpwrvgnd_1
XFILLER_33_328 VGND VGND VPWR VPWR sky130_fd_sc_hd__decap_3
XTAP_TAPCELL_ROW_44_835 VGND VPWR sky130_fd_sc_hd__tapvpwrvgnd_1
XFILLER_45_199 VGND VGND VPWR VPWR sky130_fd_sc_hd__decap_3
XFILLER_61_659 VGND VGND VPWR VPWR sky130_fd_sc_hd__decap_3
XFILLER_26_380 VGND VGND VPWR VPWR sky130_fd_sc_hd__decap_3
XFILLER_121_81 VGND VGND VPWR VPWR sky130_fd_sc_hd__decap_3
XFILLER_14_564 VGND VGND VPWR VPWR sky130_fd_sc_hd__decap_3
XFILLER_41_350 VGND VGND VPWR VPWR sky130_fd_sc_hd__decap_3
XTAP_TAPCELL_ROW_24_581 VGND VPWR sky130_fd_sc_hd__tapvpwrvgnd_1
XPHY_EDGE_ROW_116_Right_116 VGND VGND VPWR VPWR sky130_fd_sc_hd__decap_3
XFILLER_115_606 VGND VGND VPWR VPWR sky130_fd_sc_hd__decap_3
XFILLER_5_240 VGND VGND VPWR VPWR sky130_fd_sc_hd__decap_3
XFILLER_115_617 VGND VGND VPWR VPWR sky130_fd_sc_hd__decap_3
XFILLER_5_251 VGND VGND VPWR VPWR sky130_fd_sc_hd__decap_3
XFILLER_5_273 VGND VGND VPWR VPWR sky130_fd_sc_hd__decap_3
XFILLER_5_284 VGND VGND VPWR VPWR sky130_fd_sc_hd__decap_3
XTAP_TAPCELL_ROW_114_1753 VGND VPWR sky130_fd_sc_hd__tapvpwrvgnd_1
XFILLER_107_190 VGND VGND VPWR VPWR sky130_fd_sc_hd__decap_3
XFILLER_96_501 VGND VGND VPWR VPWR sky130_fd_sc_hd__decap_3
XFILLER_69_715 VGND VGND VPWR VPWR sky130_fd_sc_hd__decap_3
XFILLER_68_203 VGND VGND VPWR VPWR sky130_fd_sc_hd__decap_3
X_4120_ _7300_/Q _5028_/S _4351_/A2 _7108_/Q VGND VGND VPWR VPWR _4120_/X sky130_fd_sc_hd__a22o_2
XFILLER_96_545 VGND VGND VPWR VPWR sky130_fd_sc_hd__decap_3
XFILLER_84_707 VGND VGND VPWR VPWR sky130_fd_sc_hd__decap_3
XFILLER_1_490 VGND VGND VPWR VPWR sky130_fd_sc_hd__decap_3
XFILLER_110_344 VGND VGND VPWR VPWR sky130_fd_sc_hd__decap_3
XFILLER_96_578 VGND VGND VPWR VPWR sky130_fd_sc_hd__decap_3
XFILLER_96_589 VGND VGND VPWR VPWR sky130_fd_sc_hd__decap_3
XFILLER_37_612 VGND VGND VPWR VPWR sky130_fd_sc_hd__decap_3
XFILLER_83_228 VGND VGND VPWR VPWR sky130_fd_sc_hd__decap_3
XFILLER_37_623 VGND VGND VPWR VPWR sky130_fd_sc_hd__decap_3
XFILLER_49_494 VGND VGND VPWR VPWR sky130_fd_sc_hd__decap_3
XFILLER_64_431 VGND VGND VPWR VPWR sky130_fd_sc_hd__fill_2
XFILLER_37_656 VGND VGND VPWR VPWR sky130_fd_sc_hd__decap_3
XFILLER_64_453 VGND VGND VPWR VPWR sky130_fd_sc_hd__decap_3
XTAP_TAPCELL_ROW_65_1107 VGND VPWR sky130_fd_sc_hd__tapvpwrvgnd_1
XTAP_TAPCELL_ROW_65_1118 VGND VPWR sky130_fd_sc_hd__tapvpwrvgnd_1
XFILLER_91_261 VGND VGND VPWR VPWR sky130_fd_sc_hd__fill_2
XFILLER_64_486 VGND VGND VPWR VPWR sky130_fd_sc_hd__decap_3
XFILLER_52_637 VGND VGND VPWR VPWR sky130_fd_sc_hd__decap_3
XFILLER_24_328 VGND VGND VPWR VPWR sky130_fd_sc_hd__decap_3
XFILLER_52_648 VGND VGND VPWR VPWR sky130_fd_sc_hd__decap_3
X_4953_ _4200_/A _4381_/A _4969_/C _4814_/A VGND VGND VPWR VPWR _4953_/Y sky130_fd_sc_hd__a31oi_2
XFILLER_17_391 VGND VGND VPWR VPWR sky130_fd_sc_hd__fill_1
XFILLER_51_147 VGND VGND VPWR VPWR sky130_fd_sc_hd__fill_1
X_3904_ _3904_/A _3904_/B VGND VGND VPWR VPWR _3904_/Y sky130_fd_sc_hd__nand2_2
XFILLER_51_169 VGND VGND VPWR VPWR sky130_fd_sc_hd__decap_3
X_4884_ _4884_/A _4904_/B VGND VGND VPWR VPWR _4884_/X sky130_fd_sc_hd__or2_2
XFILLER_60_681 VGND VGND VPWR VPWR sky130_fd_sc_hd__decap_3
X_6623_ _6658_/A VGND VGND VPWR VPWR _6623_/Y sky130_fd_sc_hd__inv_2
X_3835_ _6725_/Q _3661_/X _3840_/A2 _6975_/Q VGND VGND VPWR VPWR _3835_/X sky130_fd_sc_hd__a22o_2
XFILLER_20_578 VGND VGND VPWR VPWR sky130_fd_sc_hd__decap_3
X_6554_ _6649_/A VGND VGND VPWR VPWR _6554_/Y sky130_fd_sc_hd__inv_2
X_3766_ hold957/X _3857_/A2 _4927_/B VGND VGND VPWR VPWR _7394_/D sky130_fd_sc_hd__a21o_2
XFILLER_20_589 VGND VGND VPWR VPWR sky130_fd_sc_hd__decap_3
XFILLER_118_433 VGND VGND VPWR VPWR sky130_fd_sc_hd__decap_3
X_6485_ _6650_/A VGND VGND VPWR VPWR _6485_/Y sky130_fd_sc_hd__inv_2
X_3697_ _3682_/A _3696_/X _4791_/A1 VGND VGND VPWR VPWR _3697_/Y sky130_fd_sc_hd__a21oi_2
XFILLER_118_477 VGND VGND VPWR VPWR sky130_fd_sc_hd__decap_3
XFILLER_106_628 VGND VGND VPWR VPWR sky130_fd_sc_hd__decap_3
XTAP_TAPCELL_ROW_76_1258 VGND VPWR sky130_fd_sc_hd__tapvpwrvgnd_1
XFILLER_121_609 VGND VGND VPWR VPWR sky130_fd_sc_hd__decap_3
X_5367_ _5367_/A0 _4734_/X _5383_/S VGND VGND VPWR VPWR _7149_/D sky130_fd_sc_hd__mux2_2
XFILLER_114_672 VGND VGND VPWR VPWR sky130_fd_sc_hd__decap_3
X_7106_ _7365_/CLK _7106_/D _6386_/Y VGND VGND VPWR VPWR _7106_/Q sky130_fd_sc_hd__dfrtp_2
XFILLER_99_383 VGND VGND VPWR VPWR sky130_fd_sc_hd__fill_2
X_4318_ _7290_/Q _4534_/S _4348_/A2 _7162_/Q _4317_/X VGND VGND VPWR VPWR _4318_/X
+ sky130_fd_sc_hd__a221o_2
X_5298_ _5298_/A0 _4734_/X _5315_/S VGND VGND VPWR VPWR _7181_/D sky130_fd_sc_hd__mux2_2
XFILLER_87_567 VGND VGND VPWR VPWR sky130_fd_sc_hd__decap_3
X_7037_ _7355_/CLK _7037_/D _6317_/Y VGND VGND VPWR VPWR _7037_/Q sky130_fd_sc_hd__dfrtp_2
XFILLER_75_718 VGND VGND VPWR VPWR sky130_fd_sc_hd__decap_3
X_4249_ _7069_/Q _4265_/B _4460_/A VGND VGND VPWR VPWR _4626_/C sky130_fd_sc_hd__o21a_2
XFILLER_75_729 VGND VGND VPWR VPWR sky130_fd_sc_hd__decap_3
XFILLER_74_206 VGND VGND VPWR VPWR sky130_fd_sc_hd__decap_3
XFILLER_28_601 VGND VGND VPWR VPWR sky130_fd_sc_hd__decap_3
XFILLER_19_57 VGND VGND VPWR VPWR sky130_fd_sc_hd__fill_2
XFILLER_28_634 VGND VGND VPWR VPWR sky130_fd_sc_hd__decap_3
XFILLER_55_420 VGND VGND VPWR VPWR sky130_fd_sc_hd__decap_3
XFILLER_28_645 VGND VGND VPWR VPWR sky130_fd_sc_hd__decap_3
XFILLER_27_122 VGND VGND VPWR VPWR sky130_fd_sc_hd__decap_3
XFILLER_55_453 VGND VGND VPWR VPWR sky130_fd_sc_hd__decap_3
XFILLER_28_678 VGND VGND VPWR VPWR sky130_fd_sc_hd__decap_3
XTAP_TAPCELL_ROW_2_287 VGND VPWR sky130_fd_sc_hd__tapvpwrvgnd_1
XFILLER_35_23 VGND VGND VPWR VPWR sky130_fd_sc_hd__decap_3
XTAP_TAPCELL_ROW_2_298 VGND VPWR sky130_fd_sc_hd__tapvpwrvgnd_1
XFILLER_55_486 VGND VGND VPWR VPWR sky130_fd_sc_hd__decap_3
XFILLER_43_626 VGND VGND VPWR VPWR sky130_fd_sc_hd__decap_3
XFILLER_27_177 VGND VGND VPWR VPWR sky130_fd_sc_hd__fill_2
XTAP_TAPCELL_ROW_87_1398 VGND VPWR sky130_fd_sc_hd__tapvpwrvgnd_1
XFILLER_70_445 VGND VGND VPWR VPWR sky130_fd_sc_hd__decap_3
XFILLER_43_659 VGND VGND VPWR VPWR sky130_fd_sc_hd__decap_3
XTAP_TAPCELL_ROW_41_805 VGND VPWR sky130_fd_sc_hd__tapvpwrvgnd_1
XFILLER_30_309 VGND VGND VPWR VPWR sky130_fd_sc_hd__decap_3
XFILLER_70_489 VGND VGND VPWR VPWR sky130_fd_sc_hd__fill_2
XFILLER_7_505 VGND VGND VPWR VPWR sky130_fd_sc_hd__decap_3
XFILLER_51_44 VGND VGND VPWR VPWR sky130_fd_sc_hd__decap_3
XFILLER_11_556 VGND VGND VPWR VPWR sky130_fd_sc_hd__decap_3
XFILLER_11_567 VGND VGND VPWR VPWR sky130_fd_sc_hd__decap_3
XTAP_TAPCELL_ROW_21_540 VGND VPWR sky130_fd_sc_hd__tapvpwrvgnd_1
XFILLER_51_55 VGND VGND VPWR VPWR sky130_fd_sc_hd__fill_1
XFILLER_51_77 VGND VGND VPWR VPWR sky130_fd_sc_hd__decap_3
XFILLER_51_99 VGND VGND VPWR VPWR sky130_fd_sc_hd__decap_3
XFILLER_3_700 VGND VGND VPWR VPWR sky130_fd_sc_hd__decap_3
XFILLER_109_488 VGND VGND VPWR VPWR sky130_fd_sc_hd__decap_3
XPHY_EDGE_ROW_115_Left_239 VGND VGND VPWR VPWR sky130_fd_sc_hd__decap_3
XFILLER_105_650 VGND VGND VPWR VPWR sky130_fd_sc_hd__decap_3
XFILLER_2_243 VGND VGND VPWR VPWR sky130_fd_sc_hd__decap_3
XFILLER_78_501 VGND VGND VPWR VPWR sky130_fd_sc_hd__decap_3
XFILLER_111_119 VGND VGND VPWR VPWR sky130_fd_sc_hd__fill_1
XFILLER_105_694 VGND VGND VPWR VPWR sky130_fd_sc_hd__decap_3
XFILLER_78_545 VGND VGND VPWR VPWR sky130_fd_sc_hd__decap_3
XFILLER_120_631 VGND VGND VPWR VPWR sky130_fd_sc_hd__decap_3
XFILLER_104_193 VGND VGND VPWR VPWR sky130_fd_sc_hd__decap_3
XFILLER_66_707 VGND VGND VPWR VPWR sky130_fd_sc_hd__decap_3
XTAP_TAPCELL_ROW_49_905 VGND VPWR sky130_fd_sc_hd__tapvpwrvgnd_1
XFILLER_120_675 VGND VGND VPWR VPWR sky130_fd_sc_hd__decap_3
XFILLER_78_589 VGND VGND VPWR VPWR sky130_fd_sc_hd__decap_3
XFILLER_19_612 VGND VGND VPWR VPWR sky130_fd_sc_hd__decap_3
XFILLER_76_85 VGND VGND VPWR VPWR sky130_fd_sc_hd__decap_3
XFILLER_19_623 VGND VGND VPWR VPWR sky130_fd_sc_hd__decap_3
XFILLER_93_559 VGND VGND VPWR VPWR sky130_fd_sc_hd__fill_1
XFILLER_19_656 VGND VGND VPWR VPWR sky130_fd_sc_hd__decap_3
XTAP_TAPCELL_ROW_29_640 VGND VPWR sky130_fd_sc_hd__tapvpwrvgnd_1
XFILLER_80_209 VGND VGND VPWR VPWR sky130_fd_sc_hd__decap_3
XFILLER_34_604 VGND VGND VPWR VPWR sky130_fd_sc_hd__decap_3
XFILLER_73_261 VGND VGND VPWR VPWR sky130_fd_sc_hd__decap_3
XFILLER_61_412 VGND VGND VPWR VPWR sky130_fd_sc_hd__decap_3
XFILLER_34_637 VGND VGND VPWR VPWR sky130_fd_sc_hd__decap_3
XFILLER_92_51 VGND VGND VPWR VPWR sky130_fd_sc_hd__decap_3
XFILLER_34_648 VGND VGND VPWR VPWR sky130_fd_sc_hd__decap_3
XFILLER_33_125 VGND VGND VPWR VPWR sky130_fd_sc_hd__fill_1
XFILLER_61_445 VGND VGND VPWR VPWR sky130_fd_sc_hd__decap_3
XFILLER_33_158 VGND VGND VPWR VPWR sky130_fd_sc_hd__fill_1
XFILLER_33_169 VGND VGND VPWR VPWR sky130_fd_sc_hd__decap_3
XFILLER_42_681 VGND VGND VPWR VPWR sky130_fd_sc_hd__decap_3
XTAP_TAPCELL_ROW_60_1048 VGND VPWR sky130_fd_sc_hd__tapvpwrvgnd_1
X_3620_ _3620_/A _4292_/B _3620_/C VGND VGND VPWR VPWR _3620_/X sky130_fd_sc_hd__or3_4
X_3551_ _3508_/A _3547_/Y _3550_/X VGND VGND VPWR VPWR _3551_/X sky130_fd_sc_hd__a21o_2
XFILLER_6_560 VGND VGND VPWR VPWR sky130_fd_sc_hd__decap_3
XFILLER_115_403 VGND VGND VPWR VPWR sky130_fd_sc_hd__decap_3
X_6270_ _6363_/A VGND VGND VPWR VPWR _6270_/Y sky130_fd_sc_hd__inv_2
XFILLER_51_3 VGND VGND VPWR VPWR sky130_fd_sc_hd__decap_3
XFILLER_115_436 VGND VGND VPWR VPWR sky130_fd_sc_hd__decap_3
X_3482_ _3482_/A _3482_/B _3482_/C VGND VGND VPWR VPWR _3482_/Y sky130_fd_sc_hd__nor3_2
XFILLER_115_458 VGND VGND VPWR VPWR sky130_fd_sc_hd__decap_3
X_5221_ _5221_/A _5223_/B VGND VGND VPWR VPWR _7218_/D sky130_fd_sc_hd__and2_2
XFILLER_88_309 VGND VGND VPWR VPWR sky130_fd_sc_hd__decap_3
XFILLER_103_609 VGND VGND VPWR VPWR sky130_fd_sc_hd__decap_3
XFILLER_69_501 VGND VGND VPWR VPWR sky130_fd_sc_hd__decap_3
X_5152_ _7009_/Q _5152_/B VGND VGND VPWR VPWR _5152_/Y sky130_fd_sc_hd__nand2_2
XFILLER_111_620 VGND VGND VPWR VPWR sky130_fd_sc_hd__decap_3
XFILLER_123_491 VGND VGND VPWR VPWR sky130_fd_sc_hd__decap_3
XFILLER_69_556 VGND VGND VPWR VPWR sky130_fd_sc_hd__fill_1
XFILLER_111_653 VGND VGND VPWR VPWR sky130_fd_sc_hd__decap_3
X_4103_ _7365_/Q _4108_/B _4267_/B1 _7173_/Q VGND VGND VPWR VPWR _4103_/X sky130_fd_sc_hd__a22o_2
XFILLER_96_353 VGND VGND VPWR VPWR sky130_fd_sc_hd__decap_3
XTAP_TAPCELL_ROW_71_1188 VGND VPWR sky130_fd_sc_hd__tapvpwrvgnd_1
XFILLER_57_718 VGND VGND VPWR VPWR sky130_fd_sc_hd__decap_3
XFILLER_110_141 VGND VGND VPWR VPWR sky130_fd_sc_hd__fill_1
X_5083_ _5086_/A _4343_/X VGND VGND VPWR VPWR _5083_/X sky130_fd_sc_hd__or2b_2
XFILLER_57_729 VGND VGND VPWR VPWR sky130_fd_sc_hd__decap_3
XFILLER_56_206 VGND VGND VPWR VPWR sky130_fd_sc_hd__decap_3
XFILLER_111_697 VGND VGND VPWR VPWR sky130_fd_sc_hd__decap_3
X_4034_ _7150_/Q _4434_/B1 _4032_/X _4033_/X VGND VGND VPWR VPWR _4034_/X sky130_fd_sc_hd__a211o_2
XFILLER_2_93 VGND VGND VPWR VPWR sky130_fd_sc_hd__decap_3
XFILLER_112_17 VGND VGND VPWR VPWR sky130_fd_sc_hd__decap_3
XFILLER_25_615 VGND VGND VPWR VPWR sky130_fd_sc_hd__fill_1
XFILLER_80_710 VGND VGND VPWR VPWR sky130_fd_sc_hd__decap_3
XFILLER_25_626 VGND VGND VPWR VPWR sky130_fd_sc_hd__decap_3
XFILLER_92_592 VGND VGND VPWR VPWR sky130_fd_sc_hd__decap_3
XFILLER_64_283 VGND VGND VPWR VPWR sky130_fd_sc_hd__decap_3
XFILLER_25_659 VGND VGND VPWR VPWR sky130_fd_sc_hd__decap_3
XFILLER_24_136 VGND VGND VPWR VPWR sky130_fd_sc_hd__decap_3
XFILLER_24_147 VGND VGND VPWR VPWR sky130_fd_sc_hd__decap_3
XFILLER_52_467 VGND VGND VPWR VPWR sky130_fd_sc_hd__decap_3
XFILLER_40_607 VGND VGND VPWR VPWR sky130_fd_sc_hd__decap_3
XFILLER_12_309 VGND VGND VPWR VPWR sky130_fd_sc_hd__decap_3
X_4936_ _4936_/A _4936_/B VGND VGND VPWR VPWR _4936_/Y sky130_fd_sc_hd__xnor2_2
XANTENNA_10 _3331_/A VGND VGND VPWR VPWR sky130_fd_sc_hd__diode_2
X_4867_ _6998_/Q _4912_/A VGND VGND VPWR VPWR _4882_/A sky130_fd_sc_hd__nand2_2
X_6606_ _6644_/A VGND VGND VPWR VPWR _6606_/Y sky130_fd_sc_hd__inv_2
X_3818_ _3818_/A1 _3860_/S _3817_/X VGND VGND VPWR VPWR _7390_/D sky130_fd_sc_hd__o21a_2
X_4798_ _4811_/C _4795_/X _4796_/Y _4797_/X VGND VGND VPWR VPWR _5656_/A sky130_fd_sc_hd__a211o_2
XFILLER_21_36 VGND VGND VPWR VPWR sky130_fd_sc_hd__decap_3
XFILLER_118_230 VGND VGND VPWR VPWR sky130_fd_sc_hd__decap_3
X_6537_ _6542_/A VGND VGND VPWR VPWR _6537_/Y sky130_fd_sc_hd__inv_2
X_3749_ _3726_/X _3734_/X _3748_/X _3991_/A VGND VGND VPWR VPWR _3749_/Y sky130_fd_sc_hd__o31ai_2
XFILLER_4_519 VGND VGND VPWR VPWR sky130_fd_sc_hd__decap_3
XFILLER_118_285 VGND VGND VPWR VPWR sky130_fd_sc_hd__fill_2
X_6468_ _6658_/A VGND VGND VPWR VPWR _6468_/Y sky130_fd_sc_hd__inv_2
X_5419_ _5419_/A0 _5131_/X _5429_/S VGND VGND VPWR VPWR _7124_/D sky130_fd_sc_hd__mux2_2
X_6399_ _6591_/A VGND VGND VPWR VPWR _6399_/Y sky130_fd_sc_hd__inv_2
XFILLER_121_439 VGND VGND VPWR VPWR sky130_fd_sc_hd__decap_3
XFILLER_0_725 VGND VGND VPWR VPWR sky130_fd_sc_hd__decap_3
XTAP_TAPCELL_ROW_7_357 VGND VPWR sky130_fd_sc_hd__tapvpwrvgnd_1
XFILLER_102_631 VGND VGND VPWR VPWR sky130_fd_sc_hd__decap_3
XFILLER_48_707 VGND VGND VPWR VPWR sky130_fd_sc_hd__decap_3
XFILLER_102_675 VGND VGND VPWR VPWR sky130_fd_sc_hd__decap_3
XTAP_TAPCELL_ROW_89_1427 VGND VPWR sky130_fd_sc_hd__tapvpwrvgnd_1
XFILLER_101_163 VGND VGND VPWR VPWR sky130_fd_sc_hd__decap_3
XFILLER_75_548 VGND VGND VPWR VPWR sky130_fd_sc_hd__decap_3
XFILLER_46_22 VGND VGND VPWR VPWR sky130_fd_sc_hd__decap_3
XFILLER_28_442 VGND VGND VPWR VPWR sky130_fd_sc_hd__fill_2
XFILLER_62_209 VGND VGND VPWR VPWR sky130_fd_sc_hd__fill_2
XFILLER_16_604 VGND VGND VPWR VPWR sky130_fd_sc_hd__decap_3
XFILLER_83_570 VGND VGND VPWR VPWR sky130_fd_sc_hd__decap_3
XFILLER_55_261 VGND VGND VPWR VPWR sky130_fd_sc_hd__decap_3
XFILLER_43_401 VGND VGND VPWR VPWR sky130_fd_sc_hd__fill_1
XFILLER_71_721 VGND VGND VPWR VPWR sky130_fd_sc_hd__decap_3
XFILLER_46_88 VGND VGND VPWR VPWR sky130_fd_sc_hd__decap_3
XFILLER_28_486 VGND VGND VPWR VPWR sky130_fd_sc_hd__decap_3
XTAP_TAPCELL_ROW_26_610 VGND VPWR sky130_fd_sc_hd__tapvpwrvgnd_1
XFILLER_71_732 VGND VGND VPWR VPWR sky130_fd_sc_hd__decap_3
XFILLER_43_423 VGND VGND VPWR VPWR sky130_fd_sc_hd__decap_3
XFILLER_16_637 VGND VGND VPWR VPWR sky130_fd_sc_hd__decap_3
XFILLER_16_648 VGND VGND VPWR VPWR sky130_fd_sc_hd__decap_3
XTAP_TAPCELL_ROW_54_963 VGND VPWR sky130_fd_sc_hd__tapvpwrvgnd_1
XTAP_TAPCELL_ROW_54_974 VGND VPWR sky130_fd_sc_hd__tapvpwrvgnd_1
XFILLER_70_253 VGND VGND VPWR VPWR sky130_fd_sc_hd__decap_3
XFILLER_15_169 VGND VGND VPWR VPWR sky130_fd_sc_hd__decap_3
XFILLER_102_83 VGND VGND VPWR VPWR sky130_fd_sc_hd__fill_1
XFILLER_70_275 VGND VGND VPWR VPWR sky130_fd_sc_hd__decap_3
XFILLER_31_629 VGND VGND VPWR VPWR sky130_fd_sc_hd__decap_3
XFILLER_30_106 VGND VGND VPWR VPWR sky130_fd_sc_hd__decap_3
XFILLER_24_681 VGND VGND VPWR VPWR sky130_fd_sc_hd__decap_3
XFILLER_11_386 VGND VGND VPWR VPWR sky130_fd_sc_hd__decap_3
XFILLER_7_335 VGND VGND VPWR VPWR sky130_fd_sc_hd__fill_1
XFILLER_109_241 VGND VGND VPWR VPWR sky130_fd_sc_hd__decap_3
XFILLER_7_379 VGND VGND VPWR VPWR sky130_fd_sc_hd__decap_3
XFILLER_109_263 VGND VGND VPWR VPWR sky130_fd_sc_hd__decap_3
XFILLER_98_607 VGND VGND VPWR VPWR sky130_fd_sc_hd__decap_3
XFILLER_3_541 VGND VGND VPWR VPWR sky130_fd_sc_hd__decap_3
XFILLER_11_91 VGND VGND VPWR VPWR sky130_fd_sc_hd__fill_2
XTAP_TAPCELL_ROW_111_1712 VGND VPWR sky130_fd_sc_hd__tapvpwrvgnd_1
XFILLER_112_417 VGND VGND VPWR VPWR sky130_fd_sc_hd__decap_3
XFILLER_3_585 VGND VGND VPWR VPWR sky130_fd_sc_hd__decap_3
XFILLER_112_439 VGND VGND VPWR VPWR sky130_fd_sc_hd__decap_3
XFILLER_39_718 VGND VGND VPWR VPWR sky130_fd_sc_hd__decap_3
XFILLER_39_729 VGND VGND VPWR VPWR sky130_fd_sc_hd__decap_3
XFILLER_38_206 VGND VGND VPWR VPWR sky130_fd_sc_hd__decap_3
XFILLER_93_312 VGND VGND VPWR VPWR sky130_fd_sc_hd__decap_3
XFILLER_78_386 VGND VGND VPWR VPWR sky130_fd_sc_hd__fill_1
XFILLER_120_472 VGND VGND VPWR VPWR sky130_fd_sc_hd__decap_3
XFILLER_120_483 VGND VGND VPWR VPWR sky130_fd_sc_hd__decap_3
XFILLER_19_420 VGND VGND VPWR VPWR sky130_fd_sc_hd__fill_1
XFILLER_66_559 VGND VGND VPWR VPWR sky130_fd_sc_hd__decap_3
XFILLER_93_367 VGND VGND VPWR VPWR sky130_fd_sc_hd__decap_3
XFILLER_81_529 VGND VGND VPWR VPWR sky130_fd_sc_hd__decap_3
XFILLER_62_710 VGND VGND VPWR VPWR sky130_fd_sc_hd__decap_3
XFILLER_19_475 VGND VGND VPWR VPWR sky130_fd_sc_hd__decap_3
XTAP_TAPCELL_ROW_109_1685 VGND VPWR sky130_fd_sc_hd__tapvpwrvgnd_1
XFILLER_74_592 VGND VGND VPWR VPWR sky130_fd_sc_hd__decap_3
XFILLER_46_283 VGND VGND VPWR VPWR sky130_fd_sc_hd__decap_3
XFILLER_19_497 VGND VGND VPWR VPWR sky130_fd_sc_hd__decap_3
XFILLER_34_445 VGND VGND VPWR VPWR sky130_fd_sc_hd__decap_3
XFILLER_61_231 VGND VGND VPWR VPWR sky130_fd_sc_hd__decap_3
XFILLER_22_607 VGND VGND VPWR VPWR sky130_fd_sc_hd__decap_3
XTAP_TAPCELL_ROW_122_1852 VGND VPWR sky130_fd_sc_hd__tapvpwrvgnd_1
XFILLER_61_275 VGND VGND VPWR VPWR sky130_fd_sc_hd__decap_3
XFILLER_99_3 VGND VGND VPWR VPWR sky130_fd_sc_hd__decap_3
X_4721_ _3535_/B _4658_/A _4055_/A VGND VGND VPWR VPWR _4721_/Y sky130_fd_sc_hd__a21oi_2
XFILLER_30_640 VGND VGND VPWR VPWR sky130_fd_sc_hd__decap_3
XFILLER_30_651 VGND VGND VPWR VPWR sky130_fd_sc_hd__decap_3
XTAP_TAPCELL_ROW_32_679 VGND VPWR sky130_fd_sc_hd__tapvpwrvgnd_1
X_4652_ _4652_/A _4652_/B VGND VGND VPWR VPWR _4785_/A sky130_fd_sc_hd__nor2_2
XFILLER_30_684 VGND VGND VPWR VPWR sky130_fd_sc_hd__decap_3
X_3603_ _4614_/B _3603_/B VGND VGND VPWR VPWR _3603_/Y sky130_fd_sc_hd__nand2_2
X_7371_ _7371_/CLK _7371_/D _6651_/Y VGND VGND VPWR VPWR _7371_/Q sky130_fd_sc_hd__dfrtp_2
X_4583_ _4583_/A _4595_/B VGND VGND VPWR VPWR _7289_/D sky130_fd_sc_hd__and2_2
XFILLER_116_701 VGND VGND VPWR VPWR sky130_fd_sc_hd__decap_3
Xhold803 _6873_/Q VGND VGND VPWR VPWR _6873_/D sky130_fd_sc_hd__dlygate4sd3_1
X_6322_ _6642_/A VGND VGND VPWR VPWR _6322_/Y sky130_fd_sc_hd__inv_2
Xhold814 _6948_/Q VGND VGND VPWR VPWR _6948_/D sky130_fd_sc_hd__dlygate4sd3_1
XFILLER_116_734 VGND VGND VPWR VPWR sky130_fd_sc_hd__fill_1
X_3534_ _3509_/Y _3510_/X _4354_/B1 VGND VGND VPWR VPWR _3535_/B sky130_fd_sc_hd__a21oi_2
Xhold825 _6826_/Q VGND VGND VPWR VPWR _6826_/D sky130_fd_sc_hd__dlygate4sd3_1
Xhold836 _6909_/Q VGND VGND VPWR VPWR _6909_/D sky130_fd_sc_hd__dlygate4sd3_1
Xmax_cap555 _4277_/B VGND VGND VPWR VPWR _4987_/A sky130_fd_sc_hd__buf_2
Xhold847 _7055_/Q VGND VGND VPWR VPWR _7055_/D sky130_fd_sc_hd__dlygate4sd3_1
XTAP_TAPCELL_ROW_73_1217 VGND VPWR sky130_fd_sc_hd__tapvpwrvgnd_1
Xmax_cap566 _6613_/A VGND VGND VPWR VPWR _6614_/A sky130_fd_sc_hd__clkbuf_2
Xhold858 _7107_/Q VGND VGND VPWR VPWR _7107_/D sky130_fd_sc_hd__dlygate4sd3_1
Xhold869 _7085_/Q VGND VGND VPWR VPWR _7085_/D sky130_fd_sc_hd__dlygate4sd3_1
XFILLER_107_28 VGND VGND VPWR VPWR sky130_fd_sc_hd__decap_3
X_3465_ _7185_/Q _3996_/S _4278_/B1 _7377_/Q VGND VGND VPWR VPWR _3465_/X sky130_fd_sc_hd__a22o_2
XFILLER_89_629 VGND VGND VPWR VPWR sky130_fd_sc_hd__decap_3
XFILLER_88_139 VGND VGND VPWR VPWR sky130_fd_sc_hd__fill_1
XFILLER_97_662 VGND VGND VPWR VPWR sky130_fd_sc_hd__decap_3
XTAP_TAPCELL_ROW_4_316 VGND VPWR sky130_fd_sc_hd__tapvpwrvgnd_1
X_5135_ _5135_/A1 _5642_/A _4467_/Y _5134_/X VGND VGND VPWR VPWR _5135_/X sky130_fd_sc_hd__a211o_2
XFILLER_97_673 VGND VGND VPWR VPWR sky130_fd_sc_hd__decap_3
XFILLER_96_150 VGND VGND VPWR VPWR sky130_fd_sc_hd__decap_3
XFILLER_96_161 VGND VGND VPWR VPWR sky130_fd_sc_hd__decap_3
XFILLER_29_217 VGND VGND VPWR VPWR sky130_fd_sc_hd__decap_3
XFILLER_84_312 VGND VGND VPWR VPWR sky130_fd_sc_hd__decap_3
XFILLER_96_183 VGND VGND VPWR VPWR sky130_fd_sc_hd__decap_3
XFILLER_29_228 VGND VGND VPWR VPWR sky130_fd_sc_hd__fill_1
XFILLER_123_38 VGND VGND VPWR VPWR sky130_fd_sc_hd__decap_3
X_5066_ _5066_/A _5066_/B VGND VGND VPWR VPWR _6987_/D sky130_fd_sc_hd__nor2_2
X_4017_ _7310_/Q _4486_/S _4430_/B1 _7182_/Q VGND VGND VPWR VPWR _4017_/X sky130_fd_sc_hd__a22o_2
XFILLER_72_518 VGND VGND VPWR VPWR sky130_fd_sc_hd__decap_3
XFILLER_25_401 VGND VGND VPWR VPWR sky130_fd_sc_hd__fill_2
XFILLER_53_721 VGND VGND VPWR VPWR sky130_fd_sc_hd__decap_3
XFILLER_65_592 VGND VGND VPWR VPWR sky130_fd_sc_hd__decap_3
XFILLER_53_732 VGND VGND VPWR VPWR sky130_fd_sc_hd__decap_3
XFILLER_25_445 VGND VGND VPWR VPWR sky130_fd_sc_hd__decap_3
XTAP_TAPCELL_ROW_84_1357 VGND VPWR sky130_fd_sc_hd__tapvpwrvgnd_1
XFILLER_52_253 VGND VGND VPWR VPWR sky130_fd_sc_hd__fill_1
XFILLER_25_478 VGND VGND VPWR VPWR sky130_fd_sc_hd__decap_3
XFILLER_13_629 VGND VGND VPWR VPWR sky130_fd_sc_hd__decap_3
XFILLER_40_415 VGND VGND VPWR VPWR sky130_fd_sc_hd__decap_3
XFILLER_80_595 VGND VGND VPWR VPWR sky130_fd_sc_hd__decap_3
XTAP_TAPCELL_ROW_51_933 VGND VPWR sky130_fd_sc_hd__tapvpwrvgnd_1
XFILLER_12_139 VGND VGND VPWR VPWR sky130_fd_sc_hd__fill_1
X_4919_ _4937_/A _4936_/B _4938_/B VGND VGND VPWR VPWR _4920_/B sky130_fd_sc_hd__o21ba_2
XFILLER_40_459 VGND VGND VPWR VPWR sky130_fd_sc_hd__decap_3
XFILLER_21_662 VGND VGND VPWR VPWR sky130_fd_sc_hd__decap_3
XFILLER_32_46 VGND VGND VPWR VPWR sky130_fd_sc_hd__fill_1
XFILLER_21_673 VGND VGND VPWR VPWR sky130_fd_sc_hd__decap_3
XFILLER_20_150 VGND VGND VPWR VPWR sky130_fd_sc_hd__decap_3
XFILLER_119_550 VGND VGND VPWR VPWR sky130_fd_sc_hd__decap_3
XFILLER_119_561 VGND VGND VPWR VPWR sky130_fd_sc_hd__decap_3
XFILLER_107_712 VGND VGND VPWR VPWR sky130_fd_sc_hd__decap_3
XFILLER_106_200 VGND VGND VPWR VPWR sky130_fd_sc_hd__decap_3
XFILLER_4_327 VGND VGND VPWR VPWR sky130_fd_sc_hd__decap_3
XFILLER_119_594 VGND VGND VPWR VPWR sky130_fd_sc_hd__decap_3
XFILLER_122_704 VGND VGND VPWR VPWR sky130_fd_sc_hd__decap_3
XTAP_TAPCELL_ROW_95_1497 VGND VPWR sky130_fd_sc_hd__tapvpwrvgnd_1
XFILLER_106_277 VGND VGND VPWR VPWR sky130_fd_sc_hd__decap_3
XFILLER_0_500 VGND VGND VPWR VPWR sky130_fd_sc_hd__decap_3
XFILLER_79_128 VGND VGND VPWR VPWR sky130_fd_sc_hd__decap_3
XFILLER_0_522 VGND VGND VPWR VPWR sky130_fd_sc_hd__fill_2
XFILLER_121_225 VGND VGND VPWR VPWR sky130_fd_sc_hd__decap_3
XFILLER_0_533 VGND VGND VPWR VPWR sky130_fd_sc_hd__decap_3
XFILLER_88_640 VGND VGND VPWR VPWR sky130_fd_sc_hd__decap_3
XFILLER_88_651 VGND VGND VPWR VPWR sky130_fd_sc_hd__decap_3
XFILLER_94_109 VGND VGND VPWR VPWR sky130_fd_sc_hd__decap_3
XFILLER_102_461 VGND VGND VPWR VPWR sky130_fd_sc_hd__decap_3
XFILLER_88_684 VGND VGND VPWR VPWR sky130_fd_sc_hd__decap_3
XFILLER_87_161 VGND VGND VPWR VPWR sky130_fd_sc_hd__fill_2
XFILLER_75_301 VGND VGND VPWR VPWR sky130_fd_sc_hd__decap_3
XFILLER_57_54 VGND VGND VPWR VPWR sky130_fd_sc_hd__fill_2
XFILLER_75_334 VGND VGND VPWR VPWR sky130_fd_sc_hd__fill_2
XFILLER_87_194 VGND VGND VPWR VPWR sky130_fd_sc_hd__decap_3
XFILLER_90_304 VGND VGND VPWR VPWR sky130_fd_sc_hd__fill_1
XFILLER_75_389 VGND VGND VPWR VPWR sky130_fd_sc_hd__decap_3
XFILLER_44_710 VGND VGND VPWR VPWR sky130_fd_sc_hd__decap_3
XFILLER_113_60 VGND VGND VPWR VPWR sky130_fd_sc_hd__decap_3
XFILLER_28_283 VGND VGND VPWR VPWR sky130_fd_sc_hd__decap_3
XFILLER_113_93 VGND VGND VPWR VPWR sky130_fd_sc_hd__decap_3
XFILLER_43_231 VGND VGND VPWR VPWR sky130_fd_sc_hd__decap_3
XFILLER_71_551 VGND VGND VPWR VPWR sky130_fd_sc_hd__fill_1
XFILLER_31_415 VGND VGND VPWR VPWR sky130_fd_sc_hd__decap_3
XFILLER_71_595 VGND VGND VPWR VPWR sky130_fd_sc_hd__decap_3
XFILLER_12_640 VGND VGND VPWR VPWR sky130_fd_sc_hd__decap_3
XFILLER_85_9 VGND VGND VPWR VPWR sky130_fd_sc_hd__decap_3
XFILLER_12_651 VGND VGND VPWR VPWR sky130_fd_sc_hd__decap_3
XFILLER_8_622 VGND VGND VPWR VPWR sky130_fd_sc_hd__decap_3
XFILLER_12_684 VGND VGND VPWR VPWR sky130_fd_sc_hd__decap_3
XFILLER_7_121 VGND VGND VPWR VPWR sky130_fd_sc_hd__fill_2
XFILLER_11_172 VGND VGND VPWR VPWR sky130_fd_sc_hd__decap_3
XFILLER_7_132 VGND VGND VPWR VPWR sky130_fd_sc_hd__fill_2
XFILLER_8_666 VGND VGND VPWR VPWR sky130_fd_sc_hd__decap_3
XFILLER_7_154 VGND VGND VPWR VPWR sky130_fd_sc_hd__decap_3
XFILLER_8_699 VGND VGND VPWR VPWR sky130_fd_sc_hd__fill_1
XFILLER_7_187 VGND VGND VPWR VPWR sky130_fd_sc_hd__decap_3
XFILLER_113_715 VGND VGND VPWR VPWR sky130_fd_sc_hd__decap_3
XFILLER_112_214 VGND VGND VPWR VPWR sky130_fd_sc_hd__decap_3
XFILLER_98_448 VGND VGND VPWR VPWR sky130_fd_sc_hd__decap_3
XFILLER_3_382 VGND VGND VPWR VPWR sky130_fd_sc_hd__decap_3
XFILLER_112_236 VGND VGND VPWR VPWR sky130_fd_sc_hd__decap_3
XFILLER_85_109 VGND VGND VPWR VPWR sky130_fd_sc_hd__decap_3
XFILLER_79_662 VGND VGND VPWR VPWR sky130_fd_sc_hd__decap_3
XFILLER_79_673 VGND VGND VPWR VPWR sky130_fd_sc_hd__decap_3
XFILLER_78_150 VGND VGND VPWR VPWR sky130_fd_sc_hd__decap_3
XFILLER_94_610 VGND VGND VPWR VPWR sky130_fd_sc_hd__decap_3
XFILLER_66_312 VGND VGND VPWR VPWR sky130_fd_sc_hd__decap_3
XFILLER_78_183 VGND VGND VPWR VPWR sky130_fd_sc_hd__decap_3
XFILLER_94_643 VGND VGND VPWR VPWR sky130_fd_sc_hd__fill_1
XFILLER_78_194 VGND VGND VPWR VPWR sky130_fd_sc_hd__fill_2
XFILLER_66_334 VGND VGND VPWR VPWR sky130_fd_sc_hd__decap_3
XFILLER_14_3 VGND VGND VPWR VPWR sky130_fd_sc_hd__fill_1
XFILLER_94_654 VGND VGND VPWR VPWR sky130_fd_sc_hd__decap_3
XFILLER_39_559 VGND VGND VPWR VPWR sky130_fd_sc_hd__fill_1
X_6940_ _7403_/CLK _6940_/D VGND VGND VPWR VPWR _6940_/Q sky130_fd_sc_hd__dfxtp_2
XFILLER_94_687 VGND VGND VPWR VPWR sky130_fd_sc_hd__decap_3
XFILLER_93_164 VGND VGND VPWR VPWR sky130_fd_sc_hd__decap_3
XFILLER_81_304 VGND VGND VPWR VPWR sky130_fd_sc_hd__decap_3
XFILLER_54_529 VGND VGND VPWR VPWR sky130_fd_sc_hd__decap_3
XFILLER_35_721 VGND VGND VPWR VPWR sky130_fd_sc_hd__decap_3
XFILLER_81_337 VGND VGND VPWR VPWR sky130_fd_sc_hd__decap_3
XFILLER_19_272 VGND VGND VPWR VPWR sky130_fd_sc_hd__decap_3
XTAP_TAPCELL_ROW_37_749 VGND VPWR sky130_fd_sc_hd__tapvpwrvgnd_1
XFILLER_93_197 VGND VGND VPWR VPWR sky130_fd_sc_hd__decap_3
XFILLER_35_732 VGND VGND VPWR VPWR sky130_fd_sc_hd__decap_3
X_6871_ _7378_/CLK _6871_/D VGND VGND VPWR VPWR _6871_/Q sky130_fd_sc_hd__dfxtp_2
XFILLER_34_231 VGND VGND VPWR VPWR sky130_fd_sc_hd__decap_3
XFILLER_62_551 VGND VGND VPWR VPWR sky130_fd_sc_hd__decap_3
XFILLER_34_253 VGND VGND VPWR VPWR sky130_fd_sc_hd__decap_3
XFILLER_50_713 VGND VGND VPWR VPWR sky130_fd_sc_hd__decap_3
XTAP_TAPCELL_ROW_17_484 VGND VPWR sky130_fd_sc_hd__tapvpwrvgnd_1
XFILLER_34_297 VGND VGND VPWR VPWR sky130_fd_sc_hd__decap_3
X_4704_ _6994_/Q _4977_/A VGND VGND VPWR VPWR _4963_/A sky130_fd_sc_hd__and2_2
X_5684_ _7348_/Q hold914/X _5712_/S VGND VGND VPWR VPWR _6692_/D sky130_fd_sc_hd__mux2_2
XFILLER_8_70 VGND VGND VPWR VPWR sky130_fd_sc_hd__fill_1
X_4635_ _4916_/A _4916_/B _4633_/X _4634_/Y VGND VGND VPWR VPWR _4646_/A sky130_fd_sc_hd__a211o_2
XFILLER_118_27 VGND VGND VPWR VPWR sky130_fd_sc_hd__fill_1
Xhold600 _6756_/Q VGND VGND VPWR VPWR _6756_/D sky130_fd_sc_hd__dlygate4sd3_1
X_7354_ _7354_/CLK _7354_/D _6634_/Y VGND VGND VPWR VPWR _7354_/Q sky130_fd_sc_hd__dfrtp_2
XFILLER_118_38 VGND VGND VPWR VPWR sky130_fd_sc_hd__decap_3
Xhold611 _6782_/Q VGND VGND VPWR VPWR _6782_/D sky130_fd_sc_hd__dlygate4sd3_1
Xhold622 _6844_/Q VGND VGND VPWR VPWR _6844_/D sky130_fd_sc_hd__dlygate4sd3_1
XFILLER_116_542 VGND VGND VPWR VPWR sky130_fd_sc_hd__decap_3
Xhold633 _6760_/Q VGND VGND VPWR VPWR _6760_/D sky130_fd_sc_hd__dlygate4sd3_1
X_6305_ _6618_/A VGND VGND VPWR VPWR _6305_/Y sky130_fd_sc_hd__inv_2
Xhold644 _6794_/Q VGND VGND VPWR VPWR _6794_/D sky130_fd_sc_hd__dlygate4sd3_1
XFILLER_104_704 VGND VGND VPWR VPWR sky130_fd_sc_hd__decap_3
X_3517_ _3386_/B _3370_/Y _3516_/X VGND VGND VPWR VPWR _3525_/A sky130_fd_sc_hd__a21bo_2
Xhold655 _6906_/Q VGND VGND VPWR VPWR _6906_/D sky130_fd_sc_hd__dlygate4sd3_1
X_7285_ _7318_/CLK _7285_/D _6565_/Y VGND VGND VPWR VPWR _7285_/Q sky130_fd_sc_hd__dfrtp_2
XFILLER_1_308 VGND VGND VPWR VPWR sky130_fd_sc_hd__decap_3
XFILLER_116_575 VGND VGND VPWR VPWR sky130_fd_sc_hd__decap_3
X_4497_ _4497_/A0 _4563_/A _4497_/S VGND VGND VPWR VPWR _7331_/D sky130_fd_sc_hd__mux2_2
Xhold666 _6784_/Q VGND VGND VPWR VPWR _6784_/D sky130_fd_sc_hd__dlygate4sd3_1
Xhold677 _6779_/Q VGND VGND VPWR VPWR _6779_/D sky130_fd_sc_hd__dlygate4sd3_1
Xhold688 _6731_/Q VGND VGND VPWR VPWR _6731_/D sky130_fd_sc_hd__dlygate4sd3_1
XFILLER_103_225 VGND VGND VPWR VPWR sky130_fd_sc_hd__fill_1
Xhold699 _6828_/Q VGND VGND VPWR VPWR _6828_/D sky130_fd_sc_hd__dlygate4sd3_1
X_3448_ _7282_/Q _5140_/S _4352_/B1 _7154_/Q _3447_/X VGND VGND VPWR VPWR _3448_/X
+ sky130_fd_sc_hd__a221o_2
XFILLER_103_258 VGND VGND VPWR VPWR sky130_fd_sc_hd__decap_3
XFILLER_76_109 VGND VGND VPWR VPWR sky130_fd_sc_hd__decap_3
X_3379_ _7219_/Q _3377_/X _4341_/B1 _7123_/Q VGND VGND VPWR VPWR _3379_/X sky130_fd_sc_hd__a22o_2
XFILLER_69_161 VGND VGND VPWR VPWR sky130_fd_sc_hd__decap_3
XFILLER_69_172 VGND VGND VPWR VPWR sky130_fd_sc_hd__decap_3
XFILLER_85_632 VGND VGND VPWR VPWR sky130_fd_sc_hd__decap_3
X_5118_ _5118_/A _6984_/Q _5118_/C _5118_/D VGND VGND VPWR VPWR _5118_/X sky130_fd_sc_hd__or4_2
XFILLER_84_131 VGND VGND VPWR VPWR sky130_fd_sc_hd__fill_2
XFILLER_85_665 VGND VGND VPWR VPWR sky130_fd_sc_hd__decap_3
XFILLER_85_676 VGND VGND VPWR VPWR sky130_fd_sc_hd__decap_3
XFILLER_84_153 VGND VGND VPWR VPWR sky130_fd_sc_hd__decap_3
XFILLER_72_304 VGND VGND VPWR VPWR sky130_fd_sc_hd__decap_3
XFILLER_17_209 VGND VGND VPWR VPWR sky130_fd_sc_hd__decap_3
X_5049_ _5072_/B _5073_/B _5071_/B VGND VGND VPWR VPWR _5049_/X sky130_fd_sc_hd__a21bo_2
XFILLER_57_389 VGND VGND VPWR VPWR sky130_fd_sc_hd__decap_3
XFILLER_27_57 VGND VGND VPWR VPWR sky130_fd_sc_hd__decap_3
XFILLER_26_710 VGND VGND VPWR VPWR sky130_fd_sc_hd__decap_3
XFILLER_84_197 VGND VGND VPWR VPWR sky130_fd_sc_hd__decap_3
XFILLER_38_592 VGND VGND VPWR VPWR sky130_fd_sc_hd__decap_3
XFILLER_25_242 VGND VGND VPWR VPWR sky130_fd_sc_hd__decap_3
XFILLER_25_253 VGND VGND VPWR VPWR sky130_fd_sc_hd__fill_1
XFILLER_25_264 VGND VGND VPWR VPWR sky130_fd_sc_hd__decap_3
XFILLER_41_724 VGND VGND VPWR VPWR sky130_fd_sc_hd__decap_3
XFILLER_40_223 VGND VGND VPWR VPWR sky130_fd_sc_hd__decap_3
XFILLER_40_256 VGND VGND VPWR VPWR sky130_fd_sc_hd__decap_3
XFILLER_21_481 VGND VGND VPWR VPWR sky130_fd_sc_hd__fill_2
XTAP_TAPCELL_ROW_97_1526 VGND VPWR sky130_fd_sc_hd__tapvpwrvgnd_1
XFILLER_5_603 VGND VGND VPWR VPWR sky130_fd_sc_hd__decap_3
XFILLER_107_520 VGND VGND VPWR VPWR sky130_fd_sc_hd__decap_3
XFILLER_5_647 VGND VGND VPWR VPWR sky130_fd_sc_hd__decap_3
XFILLER_107_553 VGND VGND VPWR VPWR sky130_fd_sc_hd__decap_3
XFILLER_4_146 VGND VGND VPWR VPWR sky130_fd_sc_hd__fill_2
XFILLER_107_564 VGND VGND VPWR VPWR sky130_fd_sc_hd__decap_3
XFILLER_4_17 VGND VGND VPWR VPWR sky130_fd_sc_hd__decap_3
XFILLER_122_501 VGND VGND VPWR VPWR sky130_fd_sc_hd__decap_3
XFILLER_107_597 VGND VGND VPWR VPWR sky130_fd_sc_hd__decap_3
XFILLER_68_20 VGND VGND VPWR VPWR sky130_fd_sc_hd__decap_3
XFILLER_122_545 VGND VGND VPWR VPWR sky130_fd_sc_hd__decap_3
XFILLER_68_53 VGND VGND VPWR VPWR sky130_fd_sc_hd__decap_3
XFILLER_110_707 VGND VGND VPWR VPWR sky130_fd_sc_hd__decap_3
XFILLER_68_75 VGND VGND VPWR VPWR sky130_fd_sc_hd__fill_1
XFILLER_67_109 VGND VGND VPWR VPWR sky130_fd_sc_hd__decap_3
XFILLER_122_578 VGND VGND VPWR VPWR sky130_fd_sc_hd__decap_3
XFILLER_95_429 VGND VGND VPWR VPWR sky130_fd_sc_hd__decap_3
XFILLER_122_589 VGND VGND VPWR VPWR sky130_fd_sc_hd__decap_3
XFILLER_76_610 VGND VGND VPWR VPWR sky130_fd_sc_hd__decap_3
XFILLER_0_396 VGND VGND VPWR VPWR sky130_fd_sc_hd__decap_3
XFILLER_76_643 VGND VGND VPWR VPWR sky130_fd_sc_hd__fill_1
XFILLER_76_654 VGND VGND VPWR VPWR sky130_fd_sc_hd__decap_3
XFILLER_75_131 VGND VGND VPWR VPWR sky130_fd_sc_hd__decap_3
XFILLER_75_153 VGND VGND VPWR VPWR sky130_fd_sc_hd__decap_3
XFILLER_76_687 VGND VGND VPWR VPWR sky130_fd_sc_hd__decap_3
XFILLER_75_175 VGND VGND VPWR VPWR sky130_fd_sc_hd__decap_3
XFILLER_91_635 VGND VGND VPWR VPWR sky130_fd_sc_hd__decap_3
XFILLER_63_326 VGND VGND VPWR VPWR sky130_fd_sc_hd__decap_3
XFILLER_17_721 VGND VGND VPWR VPWR sky130_fd_sc_hd__decap_3
Xplace304 _3651_/Y VGND VGND VPWR VPWR _3893_/A2 sky130_fd_sc_hd__buf_2
XFILLER_84_74 VGND VGND VPWR VPWR sky130_fd_sc_hd__decap_3
XFILLER_63_337 VGND VGND VPWR VPWR sky130_fd_sc_hd__decap_3
XFILLER_17_732 VGND VGND VPWR VPWR sky130_fd_sc_hd__decap_3
XFILLER_84_85 VGND VGND VPWR VPWR sky130_fd_sc_hd__decap_3
XFILLER_29_592 VGND VGND VPWR VPWR sky130_fd_sc_hd__decap_3
Xplace315 _4948_/A VGND VGND VPWR VPWR _4829_/A sky130_fd_sc_hd__buf_2
XFILLER_90_134 VGND VGND VPWR VPWR sky130_fd_sc_hd__decap_3
XTAP_TAPCELL_ROW_106_1644 VGND VPWR sky130_fd_sc_hd__tapvpwrvgnd_1
Xplace326 _4356_/A2 VGND VGND VPWR VPWR _4422_/A2 sky130_fd_sc_hd__buf_2
XFILLER_91_668 VGND VGND VPWR VPWR sky130_fd_sc_hd__decap_3
Xplace337 _4351_/B1 VGND VGND VPWR VPWR _4267_/A2 sky130_fd_sc_hd__buf_2
XFILLER_91_679 VGND VGND VPWR VPWR sky130_fd_sc_hd__decap_3
XFILLER_90_156 VGND VGND VPWR VPWR sky130_fd_sc_hd__fill_1
XTAP_TAPCELL_ROW_34_708 VGND VPWR sky130_fd_sc_hd__tapvpwrvgnd_1
Xplace348 _5114_/A VGND VGND VPWR VPWR _5072_/A sky130_fd_sc_hd__buf_2
Xplace359 _5028_/S VGND VGND VPWR VPWR _4979_/S sky130_fd_sc_hd__buf_2
XFILLER_44_562 VGND VGND VPWR VPWR sky130_fd_sc_hd__decap_3
XFILLER_16_253 VGND VGND VPWR VPWR sky130_fd_sc_hd__decap_3
XFILLER_90_178 VGND VGND VPWR VPWR sky130_fd_sc_hd__decap_3
XFILLER_32_713 VGND VGND VPWR VPWR sky130_fd_sc_hd__decap_3
XFILLER_16_275 VGND VGND VPWR VPWR sky130_fd_sc_hd__decap_3
XFILLER_71_381 VGND VGND VPWR VPWR sky130_fd_sc_hd__decap_3
XFILLER_31_223 VGND VGND VPWR VPWR sky130_fd_sc_hd__fill_1
XFILLER_31_234 VGND VGND VPWR VPWR sky130_fd_sc_hd__decap_3
XTAP_TAPCELL_ROW_14_443 VGND VPWR sky130_fd_sc_hd__tapvpwrvgnd_1
XTAP_TAPCELL_ROW_14_454 VGND VPWR sky130_fd_sc_hd__tapvpwrvgnd_1
XFILLER_83_6 VGND VGND VPWR VPWR sky130_fd_sc_hd__fill_2
XFILLER_8_430 VGND VGND VPWR VPWR sky130_fd_sc_hd__fill_2
XFILLER_8_441 VGND VGND VPWR VPWR sky130_fd_sc_hd__decap_3
XFILLER_117_306 VGND VGND VPWR VPWR sky130_fd_sc_hd__decap_3
XFILLER_117_328 VGND VGND VPWR VPWR sky130_fd_sc_hd__decap_3
X_4420_ _7336_/Q _3943_/S _4428_/B1 _7144_/Q VGND VGND VPWR VPWR _4420_/X sky130_fd_sc_hd__a22o_2
XTAP_TAPCELL_ROW_57_1009 VGND VPWR sky130_fd_sc_hd__tapvpwrvgnd_1
XTAP_TAPCELL_ROW_117_1784 VGND VPWR sky130_fd_sc_hd__tapvpwrvgnd_1
X_4351_ _7097_/Q _4351_/A2 _4351_/B1 _7129_/Q VGND VGND VPWR VPWR _4351_/X sky130_fd_sc_hd__a22o_2
XFILLER_99_724 VGND VGND VPWR VPWR sky130_fd_sc_hd__decap_3
XFILLER_113_523 VGND VGND VPWR VPWR sky130_fd_sc_hd__decap_3
X_3302_ _3327_/B _6979_/Q _5135_/A1 VGND VGND VPWR VPWR _3302_/X sky130_fd_sc_hd__a21o_2
X_7070_ _7392_/CLK _7070_/D _6350_/Y VGND VGND VPWR VPWR _7070_/Q sky130_fd_sc_hd__dfrtp_2
X_4282_ _7062_/Q _4305_/B _3429_/X _4281_/X VGND VGND VPWR VPWR _4282_/Y sky130_fd_sc_hd__o211ai_2
XFILLER_113_556 VGND VGND VPWR VPWR sky130_fd_sc_hd__decap_3
XFILLER_98_256 VGND VGND VPWR VPWR sky130_fd_sc_hd__decap_3
XFILLER_3_190 VGND VGND VPWR VPWR sky130_fd_sc_hd__decap_3
XFILLER_113_567 VGND VGND VPWR VPWR sky130_fd_sc_hd__decap_3
XFILLER_101_718 VGND VGND VPWR VPWR sky130_fd_sc_hd__decap_3
XFILLER_101_729 VGND VGND VPWR VPWR sky130_fd_sc_hd__decap_3
XFILLER_100_206 VGND VGND VPWR VPWR sky130_fd_sc_hd__decap_3
XFILLER_39_301 VGND VGND VPWR VPWR sky130_fd_sc_hd__decap_3
XFILLER_67_632 VGND VGND VPWR VPWR sky130_fd_sc_hd__decap_3
XFILLER_39_323 VGND VGND VPWR VPWR sky130_fd_sc_hd__decap_3
XFILLER_100_239 VGND VGND VPWR VPWR sky130_fd_sc_hd__decap_3
XFILLER_67_665 VGND VGND VPWR VPWR sky130_fd_sc_hd__decap_3
XFILLER_67_676 VGND VGND VPWR VPWR sky130_fd_sc_hd__decap_3
XFILLER_82_613 VGND VGND VPWR VPWR sky130_fd_sc_hd__decap_3
XFILLER_81_101 VGND VGND VPWR VPWR sky130_fd_sc_hd__decap_3
XFILLER_54_315 VGND VGND VPWR VPWR sky130_fd_sc_hd__decap_3
XFILLER_27_529 VGND VGND VPWR VPWR sky130_fd_sc_hd__fill_1
XTAP_TAPCELL_ROW_68_1149 VGND VPWR sky130_fd_sc_hd__tapvpwrvgnd_1
XFILLER_66_197 VGND VGND VPWR VPWR sky130_fd_sc_hd__fill_1
XFILLER_82_657 VGND VGND VPWR VPWR sky130_fd_sc_hd__decap_3
XFILLER_54_348 VGND VGND VPWR VPWR sky130_fd_sc_hd__decap_3
X_6923_ _6965_/CLK _6923_/D VGND VGND VPWR VPWR _6923_/Q sky130_fd_sc_hd__dfxtp_2
XFILLER_81_156 VGND VGND VPWR VPWR sky130_fd_sc_hd__fill_2
XFILLER_120_17 VGND VGND VPWR VPWR sky130_fd_sc_hd__decap_3
XTAP_TAPCELL_ROW_81_1316 VGND VPWR sky130_fd_sc_hd__tapvpwrvgnd_1
XFILLER_81_189 VGND VGND VPWR VPWR sky130_fd_sc_hd__decap_3
XFILLER_50_510 VGND VGND VPWR VPWR sky130_fd_sc_hd__fill_1
XFILLER_23_724 VGND VGND VPWR VPWR sky130_fd_sc_hd__decap_3
X_6854_ _6960_/CLK _6854_/D VGND VGND VPWR VPWR _6854_/Q sky130_fd_sc_hd__dfxtp_2
XFILLER_90_690 VGND VGND VPWR VPWR sky130_fd_sc_hd__decap_3
Xfanout27 _6598_/A VGND VGND VPWR VPWR _6626_/A sky130_fd_sc_hd__clkdlybuf4s25_1
Xfanout38 fanout47/X VGND VGND VPWR VPWR _6542_/A sky130_fd_sc_hd__clkdlybuf4s25_1
Xfanout49 _6685_/A VGND VGND VPWR VPWR _6684_/A sky130_fd_sc_hd__buf_2
X_6785_ _7378_/CLK _6785_/D VGND VGND VPWR VPWR _6785_/Q sky130_fd_sc_hd__dfxtp_2
XFILLER_22_256 VGND VGND VPWR VPWR sky130_fd_sc_hd__decap_3
XFILLER_10_407 VGND VGND VPWR VPWR sky130_fd_sc_hd__decap_3
XFILLER_50_598 VGND VGND VPWR VPWR sky130_fd_sc_hd__decap_3
X_5667_ _5667_/A _5668_/B VGND VGND VPWR VPWR _6979_/D sky130_fd_sc_hd__nor2_2
X_7406_ _7406_/CLK _7406_/D _6686_/Y VGND VGND VPWR VPWR _7406_/Q sky130_fd_sc_hd__dfrtp_2
XTAP_TAPCELL_ROW_79_1289 VGND VPWR sky130_fd_sc_hd__tapvpwrvgnd_1
X_5598_ hold949/X _5647_/A _4468_/X VGND VGND VPWR VPWR _7028_/D sky130_fd_sc_hd__a21o_2
X_7337_ _7399_/CLK _7337_/D _6617_/Y VGND VGND VPWR VPWR _7337_/Q sky130_fd_sc_hd__dfrtp_2
XFILLER_2_617 VGND VGND VPWR VPWR sky130_fd_sc_hd__decap_3
XFILLER_116_361 VGND VGND VPWR VPWR sky130_fd_sc_hd__decap_3
XTAP_TAPCELL_ROW_92_1467 VGND VPWR sky130_fd_sc_hd__tapvpwrvgnd_1
XFILLER_89_234 VGND VGND VPWR VPWR sky130_fd_sc_hd__decap_3
X_7268_ _7362_/CLK _7268_/D _6548_/Y VGND VGND VPWR VPWR _7268_/Q sky130_fd_sc_hd__dfrtp_2
XFILLER_104_545 VGND VGND VPWR VPWR sky130_fd_sc_hd__decap_3
XFILLER_89_267 VGND VGND VPWR VPWR sky130_fd_sc_hd__decap_3
XFILLER_104_578 VGND VGND VPWR VPWR sky130_fd_sc_hd__decap_3
XFILLER_104_589 VGND VGND VPWR VPWR sky130_fd_sc_hd__decap_3
X_7199_ _7362_/CLK _7199_/D _6479_/Y VGND VGND VPWR VPWR _7199_/Q sky130_fd_sc_hd__dfrtp_2
XFILLER_58_632 VGND VGND VPWR VPWR sky130_fd_sc_hd__decap_3
XFILLER_58_654 VGND VGND VPWR VPWR sky130_fd_sc_hd__decap_3
Xhold1130 _7119_/Q VGND VGND VPWR VPWR _5429_/A0 sky130_fd_sc_hd__dlygate4sd3_1
Xhold1141 _7246_/Q VGND VGND VPWR VPWR _5163_/A sky130_fd_sc_hd__dlygate4sd3_1
XFILLER_85_462 VGND VGND VPWR VPWR sky130_fd_sc_hd__decap_3
XFILLER_73_602 VGND VGND VPWR VPWR sky130_fd_sc_hd__decap_3
Xhold1152 _7166_/Q VGND VGND VPWR VPWR _5329_/A0 sky130_fd_sc_hd__dlygate4sd3_1
XFILLER_58_687 VGND VGND VPWR VPWR sky130_fd_sc_hd__decap_3
XFILLER_57_164 VGND VGND VPWR VPWR sky130_fd_sc_hd__decap_3
Xhold1163 _7176_/Q VGND VGND VPWR VPWR _5308_/A0 sky130_fd_sc_hd__dlygate4sd3_1
XFILLER_18_529 VGND VGND VPWR VPWR sky130_fd_sc_hd__decap_3
Xhold1174 _7181_/Q VGND VGND VPWR VPWR _5298_/A0 sky130_fd_sc_hd__dlygate4sd3_1
XFILLER_73_635 VGND VGND VPWR VPWR sky130_fd_sc_hd__decap_3
Xhold1185 _7380_/Q VGND VGND VPWR VPWR _3905_/A1 sky130_fd_sc_hd__dlygate4sd3_1
XFILLER_72_112 VGND VGND VPWR VPWR sky130_fd_sc_hd__decap_3
Xhold1196 _7165_/Q VGND VGND VPWR VPWR _5331_/A0 sky130_fd_sc_hd__dlygate4sd3_1
XFILLER_57_197 VGND VGND VPWR VPWR sky130_fd_sc_hd__decap_3
XFILLER_45_337 VGND VGND VPWR VPWR sky130_fd_sc_hd__decap_3
XFILLER_73_668 VGND VGND VPWR VPWR sky130_fd_sc_hd__decap_3
XFILLER_73_679 VGND VGND VPWR VPWR sky130_fd_sc_hd__decap_3
XFILLER_72_156 VGND VGND VPWR VPWR sky130_fd_sc_hd__decap_3
XFILLER_14_713 VGND VGND VPWR VPWR sky130_fd_sc_hd__decap_3
XFILLER_72_189 VGND VGND VPWR VPWR sky130_fd_sc_hd__decap_3
XFILLER_60_329 VGND VGND VPWR VPWR sky130_fd_sc_hd__fill_2
XFILLER_53_370 VGND VGND VPWR VPWR sky130_fd_sc_hd__fill_1
XFILLER_26_595 VGND VGND VPWR VPWR sky130_fd_sc_hd__decap_3
XFILLER_13_234 VGND VGND VPWR VPWR sky130_fd_sc_hd__decap_3
XFILLER_110_50 VGND VGND VPWR VPWR sky130_fd_sc_hd__decap_3
XFILLER_9_216 VGND VGND VPWR VPWR sky130_fd_sc_hd__decap_3
XFILLER_70_21 VGND VGND VPWR VPWR sky130_fd_sc_hd__decap_3
XFILLER_13_278 VGND VGND VPWR VPWR sky130_fd_sc_hd__fill_2
XFILLER_70_32 VGND VGND VPWR VPWR sky130_fd_sc_hd__decap_3
XFILLER_41_598 VGND VGND VPWR VPWR sky130_fd_sc_hd__decap_3
XFILLER_110_83 VGND VGND VPWR VPWR sky130_fd_sc_hd__fill_1
XTAP_TAPCELL_ROW_101_1574 VGND VPWR sky130_fd_sc_hd__tapvpwrvgnd_1
XTAP_TAPCELL_ROW_101_1585 VGND VPWR sky130_fd_sc_hd__tapvpwrvgnd_1
XTAP_TAPCELL_ROW_11_413 VGND VPWR sky130_fd_sc_hd__tapvpwrvgnd_1
Xclkload19 _7345_/CLK VGND VGND VPWR VPWR clkload19/X sky130_fd_sc_hd__clkbuf_1
XFILLER_79_30 VGND VGND VPWR VPWR sky130_fd_sc_hd__decap_3
XFILLER_119_81 VGND VGND VPWR VPWR sky130_fd_sc_hd__decap_3
XFILLER_107_350 VGND VGND VPWR VPWR sky130_fd_sc_hd__decap_3
XFILLER_79_63 VGND VGND VPWR VPWR sky130_fd_sc_hd__decap_3
XFILLER_96_716 VGND VGND VPWR VPWR sky130_fd_sc_hd__decap_3
XFILLER_1_650 VGND VGND VPWR VPWR sky130_fd_sc_hd__decap_3
XFILLER_49_632 VGND VGND VPWR VPWR sky130_fd_sc_hd__decap_3
XFILLER_1_694 VGND VGND VPWR VPWR sky130_fd_sc_hd__decap_3
XFILLER_110_548 VGND VGND VPWR VPWR sky130_fd_sc_hd__decap_3
XFILLER_49_665 VGND VGND VPWR VPWR sky130_fd_sc_hd__decap_3
XFILLER_49_676 VGND VGND VPWR VPWR sky130_fd_sc_hd__decap_3
XFILLER_64_613 VGND VGND VPWR VPWR sky130_fd_sc_hd__decap_3
XFILLER_91_410 VGND VGND VPWR VPWR sky130_fd_sc_hd__decap_3
XFILLER_48_175 VGND VGND VPWR VPWR sky130_fd_sc_hd__fill_1
XFILLER_36_315 VGND VGND VPWR VPWR sky130_fd_sc_hd__decap_3
XTAP_TAPCELL_ROW_19_513 VGND VPWR sky130_fd_sc_hd__tapvpwrvgnd_1
XFILLER_48_186 VGND VGND VPWR VPWR sky130_fd_sc_hd__decap_3
XFILLER_91_432 VGND VGND VPWR VPWR sky130_fd_sc_hd__decap_3
XFILLER_48_197 VGND VGND VPWR VPWR sky130_fd_sc_hd__fill_1
XFILLER_64_657 VGND VGND VPWR VPWR sky130_fd_sc_hd__decap_3
XTAP_TAPCELL_ROW_47_877 VGND VPWR sky130_fd_sc_hd__tapvpwrvgnd_1
XFILLER_91_476 VGND VGND VPWR VPWR sky130_fd_sc_hd__fill_2
XFILLER_63_167 VGND VGND VPWR VPWR sky130_fd_sc_hd__fill_1
XFILLER_63_178 VGND VGND VPWR VPWR sky130_fd_sc_hd__decap_3
X_3920_ _7377_/Q _3991_/A _3919_/X VGND VGND VPWR VPWR _7377_/D sky130_fd_sc_hd__o21a_2
XFILLER_17_573 VGND VGND VPWR VPWR sky130_fd_sc_hd__decap_3
XFILLER_32_510 VGND VGND VPWR VPWR sky130_fd_sc_hd__decap_3
XFILLER_72_690 VGND VGND VPWR VPWR sky130_fd_sc_hd__decap_3
X_3851_ _6825_/Q _3851_/A2 _3651_/Y _6815_/Q _3850_/X VGND VGND VPWR VPWR _3851_/X
+ sky130_fd_sc_hd__a221o_2
XFILLER_20_716 VGND VGND VPWR VPWR sky130_fd_sc_hd__decap_3
X_6570_ _6570_/A VGND VGND VPWR VPWR _6570_/Y sky130_fd_sc_hd__inv_2
XFILLER_81_3 VGND VGND VPWR VPWR sky130_fd_sc_hd__decap_3
XFILLER_32_598 VGND VGND VPWR VPWR sky130_fd_sc_hd__decap_3
X_3782_ _6827_/Q _3661_/X _3840_/A2 _6817_/Q VGND VGND VPWR VPWR _3782_/X sky130_fd_sc_hd__a22o_2
XTAP_TAPCELL_ROW_119_1813 VGND VPWR sky130_fd_sc_hd__tapvpwrvgnd_1
XFILLER_118_604 VGND VGND VPWR VPWR sky130_fd_sc_hd__decap_3
XFILLER_118_637 VGND VGND VPWR VPWR sky130_fd_sc_hd__decap_3
XFILLER_8_271 VGND VGND VPWR VPWR sky130_fd_sc_hd__decap_3
XFILLER_118_648 VGND VGND VPWR VPWR sky130_fd_sc_hd__decap_3
XFILLER_117_158 VGND VGND VPWR VPWR sky130_fd_sc_hd__decap_3
Xoutput502 _3421_/B VGND VGND VPWR VPWR instruction_out[20] sky130_fd_sc_hd__clkdlybuf4s25_1
X_4403_ _4403_/A VGND VGND VPWR VPWR _4411_/A sky130_fd_sc_hd__inv_2
Xoutput513 _5642_/A VGND VGND VPWR VPWR instruction_out[3] sky130_fd_sc_hd__clkdlybuf4s25_1
X_5383_ _7141_/Q _4878_/X _5383_/S VGND VGND VPWR VPWR _7141_/D sky130_fd_sc_hd__mux2_2
Xoutput524 _6990_/Q VGND VGND VPWR VPWR pc_out[13] sky130_fd_sc_hd__clkdlybuf4s25_1
Xoutput535 _7000_/Q VGND VGND VPWR VPWR pc_out[23] sky130_fd_sc_hd__clkdlybuf4s25_1
Xoutput546 _5135_/A1 VGND VGND VPWR VPWR pc_out[4] sky130_fd_sc_hd__clkdlybuf4s25_1
X_7122_ _7355_/CLK _7122_/D _6402_/Y VGND VGND VPWR VPWR _7122_/Q sky130_fd_sc_hd__dfrtp_2
X_4334_ _7351_/Q _4270_/B _4352_/B1 _7159_/Q VGND VGND VPWR VPWR _4336_/B sky130_fd_sc_hd__a22o_2
XFILLER_99_576 VGND VGND VPWR VPWR sky130_fd_sc_hd__decap_3
XFILLER_87_727 VGND VGND VPWR VPWR sky130_fd_sc_hd__fill_1
X_7053_ _7406_/CLK _7053_/D _6333_/Y VGND VGND VPWR VPWR _7053_/Q sky130_fd_sc_hd__dfrtp_2
XFILLER_115_28 VGND VGND VPWR VPWR sky130_fd_sc_hd__decap_3
X_4265_ _7070_/Q _4265_/B VGND VGND VPWR VPWR _4376_/C sky130_fd_sc_hd__nor2_2
XFILLER_86_215 VGND VGND VPWR VPWR sky130_fd_sc_hd__decap_3
XFILLER_86_248 VGND VGND VPWR VPWR sky130_fd_sc_hd__decap_3
XFILLER_86_259 VGND VGND VPWR VPWR sky130_fd_sc_hd__decap_3
X_4196_ _7391_/Q _4268_/B1 _5028_/S _7295_/Q _4195_/X VGND VGND VPWR VPWR _4196_/X
+ sky130_fd_sc_hd__a221o_2
XFILLER_67_473 VGND VGND VPWR VPWR sky130_fd_sc_hd__decap_3
XFILLER_54_101 VGND VGND VPWR VPWR sky130_fd_sc_hd__fill_2
XFILLER_39_175 VGND VGND VPWR VPWR sky130_fd_sc_hd__decap_3
XPHY_EDGE_ROW_19_Left_143 VGND VGND VPWR VPWR sky130_fd_sc_hd__decap_3
XFILLER_55_635 VGND VGND VPWR VPWR sky130_fd_sc_hd__decap_3
XFILLER_27_326 VGND VGND VPWR VPWR sky130_fd_sc_hd__fill_1
XFILLER_27_337 VGND VGND VPWR VPWR sky130_fd_sc_hd__decap_3
XFILLER_55_668 VGND VGND VPWR VPWR sky130_fd_sc_hd__decap_3
XFILLER_55_679 VGND VGND VPWR VPWR sky130_fd_sc_hd__decap_3
XFILLER_70_616 VGND VGND VPWR VPWR sky130_fd_sc_hd__decap_3
XFILLER_42_307 VGND VGND VPWR VPWR sky130_fd_sc_hd__fill_1
XFILLER_54_178 VGND VGND VPWR VPWR sky130_fd_sc_hd__decap_3
X_6906_ clkload4/A _6906_/D VGND VGND VPWR VPWR _6906_/Q sky130_fd_sc_hd__dfxtp_2
XFILLER_35_381 VGND VGND VPWR VPWR sky130_fd_sc_hd__decap_3
X_6837_ _6967_/CLK _6837_/D VGND VGND VPWR VPWR _6837_/Q sky130_fd_sc_hd__dfxtp_2
XFILLER_23_565 VGND VGND VPWR VPWR sky130_fd_sc_hd__decap_3
XFILLER_11_727 VGND VGND VPWR VPWR sky130_fd_sc_hd__fill_1
XFILLER_23_598 VGND VGND VPWR VPWR sky130_fd_sc_hd__decap_3
X_6768_ clkload5/A _6768_/D VGND VGND VPWR VPWR _6768_/Q sky130_fd_sc_hd__dfxtp_2
XFILLER_7_709 VGND VGND VPWR VPWR sky130_fd_sc_hd__decap_3
XFILLER_10_259 VGND VGND VPWR VPWR sky130_fd_sc_hd__decap_3
XFILLER_109_615 VGND VGND VPWR VPWR sky130_fd_sc_hd__fill_1
X_5719_ _7365_/Q hold921/X _5735_/S VGND VGND VPWR VPWR _6709_/D sky130_fd_sc_hd__mux2_2
XFILLER_109_626 VGND VGND VPWR VPWR sky130_fd_sc_hd__decap_3
XPHY_EDGE_ROW_28_Left_152 VGND VGND VPWR VPWR sky130_fd_sc_hd__decap_3
X_6699_ _7345_/CLK _6699_/D VGND VGND VPWR VPWR _6699_/Q sky130_fd_sc_hd__dfxtp_2
XFILLER_108_125 VGND VGND VPWR VPWR sky130_fd_sc_hd__decap_3
XFILLER_40_46 VGND VGND VPWR VPWR sky130_fd_sc_hd__decap_3
XFILLER_109_659 VGND VGND VPWR VPWR sky130_fd_sc_hd__decap_3
XFILLER_40_68 VGND VGND VPWR VPWR sky130_fd_sc_hd__decap_3
XFILLER_108_147 VGND VGND VPWR VPWR sky130_fd_sc_hd__decap_3
XFILLER_123_128 VGND VGND VPWR VPWR sky130_fd_sc_hd__decap_3
XFILLER_78_716 VGND VGND VPWR VPWR sky130_fd_sc_hd__decap_3
XFILLER_49_55 VGND VGND VPWR VPWR sky130_fd_sc_hd__fill_1
XFILLER_104_386 VGND VGND VPWR VPWR sky130_fd_sc_hd__decap_3
XFILLER_49_77 VGND VGND VPWR VPWR sky130_fd_sc_hd__fill_1
XFILLER_77_248 VGND VGND VPWR VPWR sky130_fd_sc_hd__decap_3
XFILLER_77_259 VGND VGND VPWR VPWR sky130_fd_sc_hd__decap_3
XFILLER_1_18 VGND VGND VPWR VPWR sky130_fd_sc_hd__decap_3
XPHY_EDGE_ROW_37_Left_161 VGND VGND VPWR VPWR sky130_fd_sc_hd__decap_3
XFILLER_105_50 VGND VGND VPWR VPWR sky130_fd_sc_hd__decap_3
XFILLER_58_462 VGND VGND VPWR VPWR sky130_fd_sc_hd__decap_3
XFILLER_46_602 VGND VGND VPWR VPWR sky130_fd_sc_hd__decap_3
XFILLER_46_635 VGND VGND VPWR VPWR sky130_fd_sc_hd__decap_3
XFILLER_85_281 VGND VGND VPWR VPWR sky130_fd_sc_hd__decap_3
XFILLER_100_592 VGND VGND VPWR VPWR sky130_fd_sc_hd__decap_3
XFILLER_73_443 VGND VGND VPWR VPWR sky130_fd_sc_hd__decap_3
XFILLER_46_657 VGND VGND VPWR VPWR sky130_fd_sc_hd__decap_3
XFILLER_33_307 VGND VGND VPWR VPWR sky130_fd_sc_hd__decap_3
XFILLER_45_178 VGND VGND VPWR VPWR sky130_fd_sc_hd__decap_3
XTAP_TAPCELL_ROW_103_1603 VGND VPWR sky130_fd_sc_hd__tapvpwrvgnd_1
XFILLER_61_638 VGND VGND VPWR VPWR sky130_fd_sc_hd__decap_3
XTAP_TAPCELL_ROW_44_836 VGND VPWR sky130_fd_sc_hd__tapvpwrvgnd_1
XFILLER_54_690 VGND VGND VPWR VPWR sky130_fd_sc_hd__decap_3
XFILLER_121_60 VGND VGND VPWR VPWR sky130_fd_sc_hd__decap_3
XFILLER_26_392 VGND VGND VPWR VPWR sky130_fd_sc_hd__decap_3
XFILLER_14_543 VGND VGND VPWR VPWR sky130_fd_sc_hd__decap_3
XFILLER_121_93 VGND VGND VPWR VPWR sky130_fd_sc_hd__decap_3
XFILLER_41_340 VGND VGND VPWR VPWR sky130_fd_sc_hd__decap_3
XFILLER_14_576 VGND VGND VPWR VPWR sky130_fd_sc_hd__decap_3
XFILLER_14_598 VGND VGND VPWR VPWR sky130_fd_sc_hd__decap_3
XPHY_EDGE_ROW_46_Left_170 VGND VGND VPWR VPWR sky130_fd_sc_hd__decap_3
XTAP_TAPCELL_ROW_24_582 VGND VPWR sky130_fd_sc_hd__tapvpwrvgnd_1
XFILLER_6_731 VGND VGND VPWR VPWR sky130_fd_sc_hd__decap_3
XFILLER_115_629 VGND VGND VPWR VPWR sky130_fd_sc_hd__decap_3
XFILLER_114_117 VGND VGND VPWR VPWR sky130_fd_sc_hd__fill_2
XFILLER_108_681 VGND VGND VPWR VPWR sky130_fd_sc_hd__decap_3
XTAP_TAPCELL_ROW_114_1743 VGND VPWR sky130_fd_sc_hd__tapvpwrvgnd_1
XTAP_TAPCELL_ROW_114_1754 VGND VPWR sky130_fd_sc_hd__tapvpwrvgnd_1
XFILLER_5_296 VGND VGND VPWR VPWR sky130_fd_sc_hd__decap_3
XFILLER_123_662 VGND VGND VPWR VPWR sky130_fd_sc_hd__decap_3
XFILLER_69_727 VGND VGND VPWR VPWR sky130_fd_sc_hd__fill_1
XFILLER_68_215 VGND VGND VPWR VPWR sky130_fd_sc_hd__decap_3
XFILLER_123_684 VGND VGND VPWR VPWR sky130_fd_sc_hd__decap_3
XFILLER_110_312 VGND VGND VPWR VPWR sky130_fd_sc_hd__fill_2
XFILLER_110_323 VGND VGND VPWR VPWR sky130_fd_sc_hd__fill_1
XFILLER_96_557 VGND VGND VPWR VPWR sky130_fd_sc_hd__decap_3
X_4050_ _7053_/Q _4488_/S _4437_/B1 _7405_/Q _4049_/X VGND VGND VPWR VPWR _4050_/X
+ sky130_fd_sc_hd__a221o_2
XFILLER_68_259 VGND VGND VPWR VPWR sky130_fd_sc_hd__decap_3
XFILLER_84_719 VGND VGND VPWR VPWR sky130_fd_sc_hd__decap_3
XFILLER_110_356 VGND VGND VPWR VPWR sky130_fd_sc_hd__decap_3
XFILLER_83_207 VGND VGND VPWR VPWR sky130_fd_sc_hd__decap_3
XFILLER_49_473 VGND VGND VPWR VPWR sky130_fd_sc_hd__fill_2
XFILLER_64_421 VGND VGND VPWR VPWR sky130_fd_sc_hd__fill_2
XFILLER_37_635 VGND VGND VPWR VPWR sky130_fd_sc_hd__decap_3
XFILLER_36_112 VGND VGND VPWR VPWR sky130_fd_sc_hd__fill_2
XFILLER_37_668 VGND VGND VPWR VPWR sky130_fd_sc_hd__decap_3
XFILLER_91_240 VGND VGND VPWR VPWR sky130_fd_sc_hd__decap_3
XFILLER_37_679 VGND VGND VPWR VPWR sky130_fd_sc_hd__decap_3
XTAP_TAPCELL_ROW_65_1108 VGND VPWR sky130_fd_sc_hd__tapvpwrvgnd_1
XFILLER_52_616 VGND VGND VPWR VPWR sky130_fd_sc_hd__decap_3
XFILLER_24_307 VGND VGND VPWR VPWR sky130_fd_sc_hd__fill_1
XFILLER_24_318 VGND VGND VPWR VPWR sky130_fd_sc_hd__fill_1
X_4952_ _4967_/B _4968_/A VGND VGND VPWR VPWR _4969_/C sky130_fd_sc_hd__or2b_2
XFILLER_91_284 VGND VGND VPWR VPWR sky130_fd_sc_hd__decap_3
X_3903_ _6782_/Q _3926_/B1 _3925_/A2 _6692_/Q _3902_/X VGND VGND VPWR VPWR _3904_/B
+ sky130_fd_sc_hd__a221o_2
XFILLER_60_660 VGND VGND VPWR VPWR sky130_fd_sc_hd__decap_3
XFILLER_32_351 VGND VGND VPWR VPWR sky130_fd_sc_hd__decap_3
XFILLER_20_502 VGND VGND VPWR VPWR sky130_fd_sc_hd__decap_3
X_6622_ _6622_/A VGND VGND VPWR VPWR _6622_/Y sky130_fd_sc_hd__inv_2
XFILLER_60_693 VGND VGND VPWR VPWR sky130_fd_sc_hd__decap_3
X_6553_ _6553_/A VGND VGND VPWR VPWR _6553_/Y sky130_fd_sc_hd__inv_2
X_3765_ _3629_/Y _3764_/X _3860_/S VGND VGND VPWR VPWR _4927_/B sky130_fd_sc_hd__o21a_2
XFILLER_9_591 VGND VGND VPWR VPWR sky130_fd_sc_hd__decap_3
X_6484_ _6643_/A VGND VGND VPWR VPWR _6484_/Y sky130_fd_sc_hd__inv_2
XFILLER_118_456 VGND VGND VPWR VPWR sky130_fd_sc_hd__fill_2
X_3696_ _6940_/Q _3898_/A2 _3759_/A2 _6804_/Q _3695_/X VGND VGND VPWR VPWR _3696_/X
+ sky130_fd_sc_hd__a221o_2
XFILLER_118_467 VGND VGND VPWR VPWR sky130_fd_sc_hd__decap_3
XFILLER_106_607 VGND VGND VPWR VPWR sky130_fd_sc_hd__decap_3
XFILLER_118_489 VGND VGND VPWR VPWR sky130_fd_sc_hd__decap_3
XFILLER_10_27 VGND VGND VPWR VPWR sky130_fd_sc_hd__fill_1
XTAP_TAPCELL_ROW_76_1259 VGND VPWR sky130_fd_sc_hd__tapvpwrvgnd_1
XFILLER_114_640 VGND VGND VPWR VPWR sky130_fd_sc_hd__decap_3
XFILLER_99_340 VGND VGND VPWR VPWR sky130_fd_sc_hd__decap_3
XFILLER_114_651 VGND VGND VPWR VPWR sky130_fd_sc_hd__decap_3
XFILLER_120_109 VGND VGND VPWR VPWR sky130_fd_sc_hd__decap_3
X_4317_ _7322_/Q _3975_/S _4346_/B1 _7354_/Q _4248_/A VGND VGND VPWR VPWR _4317_/X
+ sky130_fd_sc_hd__a221o_2
X_7105_ _7365_/CLK _7105_/D _6385_/Y VGND VGND VPWR VPWR _7105_/Q sky130_fd_sc_hd__dfrtp_2
XFILLER_114_684 VGND VGND VPWR VPWR sky130_fd_sc_hd__decap_3
XFILLER_113_172 VGND VGND VPWR VPWR sky130_fd_sc_hd__decap_3
XFILLER_59_237 VGND VGND VPWR VPWR sky130_fd_sc_hd__fill_2
XFILLER_101_323 VGND VGND VPWR VPWR sky130_fd_sc_hd__decap_3
X_7036_ _7345_/CLK _7036_/D _6316_/Y VGND VGND VPWR VPWR _7036_/Q sky130_fd_sc_hd__dfrtp_2
X_4248_ _4248_/A _4248_/B _4248_/C VGND VGND VPWR VPWR _4626_/B sky130_fd_sc_hd__or3_4
XFILLER_87_579 VGND VGND VPWR VPWR sky130_fd_sc_hd__decap_3
XFILLER_101_356 VGND VGND VPWR VPWR sky130_fd_sc_hd__decap_3
XFILLER_74_218 VGND VGND VPWR VPWR sky130_fd_sc_hd__decap_3
XFILLER_28_613 VGND VGND VPWR VPWR sky130_fd_sc_hd__decap_3
X_4179_ _4173_/Y _4248_/A _4376_/A _4178_/Y VGND VGND VPWR VPWR _4186_/A sky130_fd_sc_hd__a211o_2
XFILLER_67_281 VGND VGND VPWR VPWR sky130_fd_sc_hd__decap_3
XFILLER_28_657 VGND VGND VPWR VPWR sky130_fd_sc_hd__decap_3
XFILLER_82_240 VGND VGND VPWR VPWR sky130_fd_sc_hd__decap_3
XFILLER_43_605 VGND VGND VPWR VPWR sky130_fd_sc_hd__decap_3
XTAP_TAPCELL_ROW_2_288 VGND VPWR sky130_fd_sc_hd__tapvpwrvgnd_1
XFILLER_27_167 VGND VGND VPWR VPWR sky130_fd_sc_hd__fill_1
XFILLER_82_262 VGND VGND VPWR VPWR sky130_fd_sc_hd__decap_3
XTAP_TAPCELL_ROW_2_299 VGND VPWR sky130_fd_sc_hd__tapvpwrvgnd_1
XFILLER_42_104 VGND VGND VPWR VPWR sky130_fd_sc_hd__decap_3
XFILLER_15_318 VGND VGND VPWR VPWR sky130_fd_sc_hd__decap_3
XTAP_TAPCELL_ROW_87_1399 VGND VPWR sky130_fd_sc_hd__tapvpwrvgnd_1
XFILLER_55_498 VGND VGND VPWR VPWR sky130_fd_sc_hd__decap_3
XFILLER_43_638 VGND VGND VPWR VPWR sky130_fd_sc_hd__decap_3
XFILLER_36_690 VGND VGND VPWR VPWR sky130_fd_sc_hd__decap_3
XTAP_TAPCELL_ROW_41_806 VGND VPWR sky130_fd_sc_hd__tapvpwrvgnd_1
XFILLER_23_340 VGND VGND VPWR VPWR sky130_fd_sc_hd__decap_3
XFILLER_51_671 VGND VGND VPWR VPWR sky130_fd_sc_hd__fill_1
XFILLER_51_682 VGND VGND VPWR VPWR sky130_fd_sc_hd__decap_3
XFILLER_23_384 VGND VGND VPWR VPWR sky130_fd_sc_hd__decap_3
XPHY_EDGE_ROW_14_Right_14 VGND VGND VPWR VPWR sky130_fd_sc_hd__decap_3
Xclkbuf_3_3__f_clk clkbuf_0_clk/X VGND VGND VPWR VPWR clkload1/A sky130_fd_sc_hd__clkbuf_16
XFILLER_11_535 VGND VGND VPWR VPWR sky130_fd_sc_hd__decap_3
XFILLER_50_181 VGND VGND VPWR VPWR sky130_fd_sc_hd__decap_3
XTAP_TAPCELL_ROW_21_541 VGND VPWR sky130_fd_sc_hd__tapvpwrvgnd_1
XFILLER_11_579 VGND VGND VPWR VPWR sky130_fd_sc_hd__decap_3
XFILLER_7_539 VGND VGND VPWR VPWR sky130_fd_sc_hd__decap_3
XFILLER_109_423 VGND VGND VPWR VPWR sky130_fd_sc_hd__decap_3
XFILLER_3_712 VGND VGND VPWR VPWR sky130_fd_sc_hd__decap_3
XFILLER_2_200 VGND VGND VPWR VPWR sky130_fd_sc_hd__decap_3
XFILLER_2_233 VGND VGND VPWR VPWR sky130_fd_sc_hd__decap_3
XFILLER_105_662 VGND VGND VPWR VPWR sky130_fd_sc_hd__decap_3
XFILLER_105_673 VGND VGND VPWR VPWR sky130_fd_sc_hd__decap_3
XFILLER_78_513 VGND VGND VPWR VPWR sky130_fd_sc_hd__decap_3
XFILLER_104_150 VGND VGND VPWR VPWR sky130_fd_sc_hd__decap_3
XFILLER_2_277 VGND VGND VPWR VPWR sky130_fd_sc_hd__decap_3
XFILLER_120_610 VGND VGND VPWR VPWR sky130_fd_sc_hd__decap_3
XPHY_EDGE_ROW_23_Right_23 VGND VGND VPWR VPWR sky130_fd_sc_hd__decap_3
XFILLER_76_20 VGND VGND VPWR VPWR sky130_fd_sc_hd__decap_3
XFILLER_120_643 VGND VGND VPWR VPWR sky130_fd_sc_hd__fill_1
XFILLER_116_71 VGND VGND VPWR VPWR sky130_fd_sc_hd__decap_3
XFILLER_120_654 VGND VGND VPWR VPWR sky130_fd_sc_hd__decap_3
XTAP_TAPCELL_ROW_49_906 VGND VPWR sky130_fd_sc_hd__tapvpwrvgnd_1
XFILLER_66_719 VGND VGND VPWR VPWR sky130_fd_sc_hd__decap_3
XFILLER_120_687 VGND VGND VPWR VPWR sky130_fd_sc_hd__decap_3
XFILLER_58_270 VGND VGND VPWR VPWR sky130_fd_sc_hd__decap_3
XFILLER_19_635 VGND VGND VPWR VPWR sky130_fd_sc_hd__decap_3
XFILLER_46_421 VGND VGND VPWR VPWR sky130_fd_sc_hd__decap_3
XFILLER_58_292 VGND VGND VPWR VPWR sky130_fd_sc_hd__decap_3
XTAP_TAPCELL_ROW_29_641 VGND VPWR sky130_fd_sc_hd__tapvpwrvgnd_1
XFILLER_19_668 VGND VGND VPWR VPWR sky130_fd_sc_hd__decap_3
XFILLER_73_240 VGND VGND VPWR VPWR sky130_fd_sc_hd__decap_3
XFILLER_19_679 VGND VGND VPWR VPWR sky130_fd_sc_hd__decap_3
XFILLER_34_616 VGND VGND VPWR VPWR sky130_fd_sc_hd__decap_3
XFILLER_61_424 VGND VGND VPWR VPWR sky130_fd_sc_hd__decap_3
XFILLER_18_189 VGND VGND VPWR VPWR sky130_fd_sc_hd__decap_3
XFILLER_73_284 VGND VGND VPWR VPWR sky130_fd_sc_hd__decap_3
XFILLER_92_85 VGND VGND VPWR VPWR sky130_fd_sc_hd__decap_3
XPHY_EDGE_ROW_32_Right_32 VGND VGND VPWR VPWR sky130_fd_sc_hd__decap_3
XFILLER_42_660 VGND VGND VPWR VPWR sky130_fd_sc_hd__decap_3
XFILLER_42_693 VGND VGND VPWR VPWR sky130_fd_sc_hd__decap_3
XFILLER_14_395 VGND VGND VPWR VPWR sky130_fd_sc_hd__fill_1
XTAP_TAPCELL_ROW_60_1049 VGND VPWR sky130_fd_sc_hd__tapvpwrvgnd_1
X_3550_ _4614_/A _3547_/A _3547_/B _4948_/A VGND VGND VPWR VPWR _3550_/X sky130_fd_sc_hd__a31o_2
XFILLER_6_572 VGND VGND VPWR VPWR sky130_fd_sc_hd__decap_3
XFILLER_115_415 VGND VGND VPWR VPWR sky130_fd_sc_hd__decap_3
X_3481_ _7344_/Q _4270_/B _5157_/S _7280_/Q VGND VGND VPWR VPWR _3482_/C sky130_fd_sc_hd__a22o_2
XPHY_EDGE_ROW_41_Right_41 VGND VGND VPWR VPWR sky130_fd_sc_hd__decap_3
XFILLER_44_3 VGND VGND VPWR VPWR sky130_fd_sc_hd__decap_3
XFILLER_102_109 VGND VGND VPWR VPWR sky130_fd_sc_hd__decap_3
X_5151_ _5151_/A _5659_/B VGND VGND VPWR VPWR _5151_/X sky130_fd_sc_hd__or2_2
XFILLER_123_470 VGND VGND VPWR VPWR sky130_fd_sc_hd__decap_3
XFILLER_96_321 VGND VGND VPWR VPWR sky130_fd_sc_hd__fill_2
XFILLER_96_332 VGND VGND VPWR VPWR sky130_fd_sc_hd__decap_3
XFILLER_111_632 VGND VGND VPWR VPWR sky130_fd_sc_hd__decap_3
X_4102_ _7077_/Q _4102_/B VGND VGND VPWR VPWR _4141_/B sky130_fd_sc_hd__nor2_2
X_5082_ _6986_/Q _5098_/A VGND VGND VPWR VPWR _6986_/D sky130_fd_sc_hd__xor2_2
XFILLER_111_665 VGND VGND VPWR VPWR sky130_fd_sc_hd__decap_3
XTAP_TAPCELL_ROW_71_1189 VGND VPWR sky130_fd_sc_hd__tapvpwrvgnd_1
XFILLER_96_365 VGND VGND VPWR VPWR sky130_fd_sc_hd__decap_3
XFILLER_111_676 VGND VGND VPWR VPWR sky130_fd_sc_hd__decap_3
XFILLER_110_153 VGND VGND VPWR VPWR sky130_fd_sc_hd__decap_3
XFILLER_56_218 VGND VGND VPWR VPWR sky130_fd_sc_hd__fill_2
X_4033_ _7054_/Q _4488_/S _4399_/A2 _7406_/Q VGND VGND VPWR VPWR _4033_/X sky130_fd_sc_hd__a22o_2
XFILLER_56_229 VGND VGND VPWR VPWR sky130_fd_sc_hd__decap_3
XFILLER_2_72 VGND VGND VPWR VPWR sky130_fd_sc_hd__decap_3
XFILLER_49_281 VGND VGND VPWR VPWR sky130_fd_sc_hd__decap_3
XFILLER_37_432 VGND VGND VPWR VPWR sky130_fd_sc_hd__decap_3
XFILLER_110_197 VGND VGND VPWR VPWR sky130_fd_sc_hd__decap_3
XFILLER_64_251 VGND VGND VPWR VPWR sky130_fd_sc_hd__fill_1
XFILLER_37_465 VGND VGND VPWR VPWR sky130_fd_sc_hd__decap_3
XFILLER_112_29 VGND VGND VPWR VPWR sky130_fd_sc_hd__decap_3
XFILLER_92_571 VGND VGND VPWR VPWR sky130_fd_sc_hd__decap_3
XFILLER_64_262 VGND VGND VPWR VPWR sky130_fd_sc_hd__decap_3
XFILLER_80_722 VGND VGND VPWR VPWR sky130_fd_sc_hd__decap_3
XFILLER_25_638 VGND VGND VPWR VPWR sky130_fd_sc_hd__decap_3
XFILLER_52_424 VGND VGND VPWR VPWR sky130_fd_sc_hd__decap_3
XPHY_EDGE_ROW_50_Right_50 VGND VGND VPWR VPWR sky130_fd_sc_hd__decap_3
XFILLER_18_690 VGND VGND VPWR VPWR sky130_fd_sc_hd__decap_3
XFILLER_52_446 VGND VGND VPWR VPWR sky130_fd_sc_hd__decap_3
XFILLER_24_159 VGND VGND VPWR VPWR sky130_fd_sc_hd__decap_3
X_4935_ _6995_/Q _4963_/A VGND VGND VPWR VPWR _6995_/D sky130_fd_sc_hd__xor2_2
XFILLER_40_619 VGND VGND VPWR VPWR sky130_fd_sc_hd__decap_3
XFILLER_33_671 VGND VGND VPWR VPWR sky130_fd_sc_hd__fill_1
XFILLER_33_682 VGND VGND VPWR VPWR sky130_fd_sc_hd__decap_3
XFILLER_32_170 VGND VGND VPWR VPWR sky130_fd_sc_hd__decap_3
XANTENNA_11 _7356_/Q VGND VGND VPWR VPWR sky130_fd_sc_hd__diode_2
X_6605_ _6633_/A VGND VGND VPWR VPWR _6605_/Y sky130_fd_sc_hd__inv_2
XFILLER_20_354 VGND VGND VPWR VPWR sky130_fd_sc_hd__decap_3
X_3817_ _3682_/A _3816_/X _4791_/A1 VGND VGND VPWR VPWR _3817_/X sky130_fd_sc_hd__a21o_2
XFILLER_20_365 VGND VGND VPWR VPWR sky130_fd_sc_hd__fill_2
XFILLER_119_721 VGND VGND VPWR VPWR sky130_fd_sc_hd__decap_3
X_4797_ _4970_/A1 _4648_/A _4795_/A _5033_/B2 VGND VGND VPWR VPWR _4797_/X sky130_fd_sc_hd__a22o_2
XFILLER_119_732 VGND VGND VPWR VPWR sky130_fd_sc_hd__decap_3
XFILLER_20_376 VGND VGND VPWR VPWR sky130_fd_sc_hd__decap_3
X_3748_ _3735_/X _3738_/X _3740_/X _3923_/A1 _3747_/X VGND VGND VPWR VPWR _3748_/X
+ sky130_fd_sc_hd__a221o_2
X_6536_ _6624_/A VGND VGND VPWR VPWR _6536_/Y sky130_fd_sc_hd__inv_2
XFILLER_106_404 VGND VGND VPWR VPWR sky130_fd_sc_hd__decap_3
X_3679_ _6894_/Q VGND VGND VPWR VPWR _3679_/Y sky130_fd_sc_hd__inv_2
X_6467_ _6591_/A VGND VGND VPWR VPWR _6467_/Y sky130_fd_sc_hd__inv_2
X_6398_ _6622_/A VGND VGND VPWR VPWR _6398_/Y sky130_fd_sc_hd__inv_2
XFILLER_0_704 VGND VGND VPWR VPWR sky130_fd_sc_hd__decap_3
XFILLER_102_610 VGND VGND VPWR VPWR sky130_fd_sc_hd__decap_3
XFILLER_99_181 VGND VGND VPWR VPWR sky130_fd_sc_hd__decap_3
XTAP_TAPCELL_ROW_7_358 VGND VPWR sky130_fd_sc_hd__tapvpwrvgnd_1
XFILLER_102_643 VGND VGND VPWR VPWR sky130_fd_sc_hd__fill_1
XFILLER_102_654 VGND VGND VPWR VPWR sky130_fd_sc_hd__decap_3
XFILLER_101_131 VGND VGND VPWR VPWR sky130_fd_sc_hd__fill_1
XFILLER_87_365 VGND VGND VPWR VPWR sky130_fd_sc_hd__decap_3
XFILLER_48_719 VGND VGND VPWR VPWR sky130_fd_sc_hd__decap_3
XTAP_TAPCELL_ROW_89_1428 VGND VPWR sky130_fd_sc_hd__tapvpwrvgnd_1
XFILLER_102_687 VGND VGND VPWR VPWR sky130_fd_sc_hd__decap_3
X_7019_ _7404_/CLK _7019_/D _6299_/Y VGND VGND VPWR VPWR _7019_/Q sky130_fd_sc_hd__dfrtp_2
XFILLER_101_186 VGND VGND VPWR VPWR sky130_fd_sc_hd__decap_3
XFILLER_71_700 VGND VGND VPWR VPWR sky130_fd_sc_hd__decap_3
XFILLER_16_616 VGND VGND VPWR VPWR sky130_fd_sc_hd__decap_3
XTAP_TAPCELL_ROW_26_600 VGND VPWR sky130_fd_sc_hd__tapvpwrvgnd_1
XFILLER_83_582 VGND VGND VPWR VPWR sky130_fd_sc_hd__decap_3
XFILLER_55_273 VGND VGND VPWR VPWR sky130_fd_sc_hd__decap_3
XTAP_TAPCELL_ROW_26_611 VGND VPWR sky130_fd_sc_hd__tapvpwrvgnd_1
XFILLER_28_498 VGND VGND VPWR VPWR sky130_fd_sc_hd__decap_3
XFILLER_43_435 VGND VGND VPWR VPWR sky130_fd_sc_hd__fill_1
XFILLER_43_446 VGND VGND VPWR VPWR sky130_fd_sc_hd__fill_2
XFILLER_62_11 VGND VGND VPWR VPWR sky130_fd_sc_hd__decap_3
XFILLER_102_62 VGND VGND VPWR VPWR sky130_fd_sc_hd__fill_1
XTAP_TAPCELL_ROW_54_964 VGND VPWR sky130_fd_sc_hd__tapvpwrvgnd_1
XTAP_TAPCELL_ROW_54_975 VGND VPWR sky130_fd_sc_hd__tapvpwrvgnd_1
XFILLER_24_660 VGND VGND VPWR VPWR sky130_fd_sc_hd__decap_3
XFILLER_70_287 VGND VGND VPWR VPWR sky130_fd_sc_hd__decap_3
XFILLER_62_66 VGND VGND VPWR VPWR sky130_fd_sc_hd__fill_1
XFILLER_30_129 VGND VGND VPWR VPWR sky130_fd_sc_hd__decap_3
XFILLER_24_693 VGND VGND VPWR VPWR sky130_fd_sc_hd__decap_3
XFILLER_62_88 VGND VGND VPWR VPWR sky130_fd_sc_hd__decap_3
XFILLER_11_343 VGND VGND VPWR VPWR sky130_fd_sc_hd__decap_3
XFILLER_11_365 VGND VGND VPWR VPWR sky130_fd_sc_hd__fill_1
XFILLER_109_231 VGND VGND VPWR VPWR sky130_fd_sc_hd__fill_1
XFILLER_3_520 VGND VGND VPWR VPWR sky130_fd_sc_hd__decap_3
XFILLER_11_70 VGND VGND VPWR VPWR sky130_fd_sc_hd__decap_3
XFILLER_98_619 VGND VGND VPWR VPWR sky130_fd_sc_hd__decap_3
XFILLER_3_553 VGND VGND VPWR VPWR sky130_fd_sc_hd__decap_3
XTAP_TAPCELL_ROW_111_1713 VGND VPWR sky130_fd_sc_hd__tapvpwrvgnd_1
XFILLER_3_564 VGND VGND VPWR VPWR sky130_fd_sc_hd__decap_3
XFILLER_87_30 VGND VGND VPWR VPWR sky130_fd_sc_hd__decap_3
XFILLER_3_597 VGND VGND VPWR VPWR sky130_fd_sc_hd__decap_3
XFILLER_87_85 VGND VGND VPWR VPWR sky130_fd_sc_hd__decap_3
XFILLER_78_365 VGND VGND VPWR VPWR sky130_fd_sc_hd__fill_1
XFILLER_38_218 VGND VGND VPWR VPWR sky130_fd_sc_hd__decap_3
XFILLER_120_495 VGND VGND VPWR VPWR sky130_fd_sc_hd__decap_3
XFILLER_46_240 VGND VGND VPWR VPWR sky130_fd_sc_hd__decap_3
XFILLER_46_251 VGND VGND VPWR VPWR sky130_fd_sc_hd__fill_1
XFILLER_46_262 VGND VGND VPWR VPWR sky130_fd_sc_hd__decap_3
XFILLER_62_722 VGND VGND VPWR VPWR sky130_fd_sc_hd__decap_3
XTAP_TAPCELL_ROW_109_1686 VGND VPWR sky130_fd_sc_hd__tapvpwrvgnd_1
XFILLER_46_295 VGND VGND VPWR VPWR sky130_fd_sc_hd__decap_3
XFILLER_61_243 VGND VGND VPWR VPWR sky130_fd_sc_hd__decap_3
XFILLER_34_457 VGND VGND VPWR VPWR sky130_fd_sc_hd__decap_3
XFILLER_22_619 VGND VGND VPWR VPWR sky130_fd_sc_hd__decap_3
XTAP_TAPCELL_ROW_122_1853 VGND VPWR sky130_fd_sc_hd__tapvpwrvgnd_1
XFILLER_15_671 VGND VGND VPWR VPWR sky130_fd_sc_hd__fill_1
XFILLER_61_287 VGND VGND VPWR VPWR sky130_fd_sc_hd__decap_3
XFILLER_15_682 VGND VGND VPWR VPWR sky130_fd_sc_hd__decap_3
X_4720_ _4720_/A _4720_/B VGND VGND VPWR VPWR _4720_/X sky130_fd_sc_hd__xor2_2
Xclkbuf_leaf_41_clk clkbuf_leaf_1_clk/A VGND VGND VPWR VPWR _6967_/CLK sky130_fd_sc_hd__clkbuf_16
X_4651_ _4813_/A _4810_/B VGND VGND VPWR VPWR _4652_/B sky130_fd_sc_hd__and2_2
XFILLER_30_663 VGND VGND VPWR VPWR sky130_fd_sc_hd__decap_3
XFILLER_30_696 VGND VGND VPWR VPWR sky130_fd_sc_hd__decap_3
X_3602_ _4614_/A _3547_/A _3547_/B _4614_/C _4613_/B VGND VGND VPWR VPWR _3603_/B
+ sky130_fd_sc_hd__a41o_2
X_7370_ _7370_/CLK _7370_/D _6650_/Y VGND VGND VPWR VPWR _7370_/Q sky130_fd_sc_hd__dfrtp_2
XFILLER_116_713 VGND VGND VPWR VPWR sky130_fd_sc_hd__decap_3
X_6321_ _6674_/A VGND VGND VPWR VPWR _6321_/Y sky130_fd_sc_hd__inv_2
Xhold804 _6739_/Q VGND VGND VPWR VPWR _6739_/D sky130_fd_sc_hd__dlygate4sd3_1
Xhold815 _6893_/Q VGND VGND VPWR VPWR _6893_/D sky130_fd_sc_hd__dlygate4sd3_1
XFILLER_115_212 VGND VGND VPWR VPWR sky130_fd_sc_hd__decap_3
Xhold826 _6802_/Q VGND VGND VPWR VPWR _6802_/D sky130_fd_sc_hd__dlygate4sd3_1
Xhold837 _6804_/Q VGND VGND VPWR VPWR _6804_/D sky130_fd_sc_hd__dlygate4sd3_1
Xmax_cap556 _4994_/A2 VGND VGND VPWR VPWR _4275_/A sky130_fd_sc_hd__clkdlybuf4s25_1
Xhold848 _7068_/Q VGND VGND VPWR VPWR _7068_/D sky130_fd_sc_hd__dlygate4sd3_1
XTAP_TAPCELL_ROW_73_1218 VGND VPWR sky130_fd_sc_hd__tapvpwrvgnd_1
Xmax_cap567 _6504_/A VGND VGND VPWR VPWR _6594_/A sky130_fd_sc_hd__buf_4
Xhold859 _7113_/Q VGND VGND VPWR VPWR _7113_/D sky130_fd_sc_hd__dlygate4sd3_1
X_5203_ _5203_/A _5225_/B VGND VGND VPWR VPWR _7227_/D sky130_fd_sc_hd__and2_2
XFILLER_88_118 VGND VGND VPWR VPWR sky130_fd_sc_hd__decap_3
X_3395_ _7059_/Q _3558_/B VGND VGND VPWR VPWR _3589_/B sky130_fd_sc_hd__nor2_2
XFILLER_97_641 VGND VGND VPWR VPWR sky130_fd_sc_hd__decap_3
XFILLER_69_343 VGND VGND VPWR VPWR sky130_fd_sc_hd__decap_3
X_5134_ _3735_/A _3908_/X _3346_/A VGND VGND VPWR VPWR _5134_/X sky130_fd_sc_hd__o21a_2
XTAP_TAPCELL_ROW_4_317 VGND VPWR sky130_fd_sc_hd__tapvpwrvgnd_1
XFILLER_97_685 VGND VGND VPWR VPWR sky130_fd_sc_hd__decap_3
XFILLER_57_516 VGND VGND VPWR VPWR sky130_fd_sc_hd__decap_3
XFILLER_69_387 VGND VGND VPWR VPWR sky130_fd_sc_hd__decap_3
XFILLER_123_17 VGND VGND VPWR VPWR sky130_fd_sc_hd__decap_3
XFILLER_111_473 VGND VGND VPWR VPWR sky130_fd_sc_hd__decap_3
XFILLER_96_173 VGND VGND VPWR VPWR sky130_fd_sc_hd__decap_3
X_5065_ _6986_/Q _5098_/A _6987_/Q VGND VGND VPWR VPWR _5066_/B sky130_fd_sc_hd__a21oi_2
XFILLER_96_195 VGND VGND VPWR VPWR sky130_fd_sc_hd__fill_1
XFILLER_84_335 VGND VGND VPWR VPWR sky130_fd_sc_hd__decap_3
XFILLER_37_240 VGND VGND VPWR VPWR sky130_fd_sc_hd__decap_3
XFILLER_53_700 VGND VGND VPWR VPWR sky130_fd_sc_hd__decap_3
XFILLER_37_284 VGND VGND VPWR VPWR sky130_fd_sc_hd__decap_3
XFILLER_25_424 VGND VGND VPWR VPWR sky130_fd_sc_hd__decap_3
XFILLER_80_541 VGND VGND VPWR VPWR sky130_fd_sc_hd__decap_3
XTAP_TAPCELL_ROW_84_1358 VGND VPWR sky130_fd_sc_hd__tapvpwrvgnd_1
XFILLER_80_574 VGND VGND VPWR VPWR sky130_fd_sc_hd__decap_3
XFILLER_12_107 VGND VGND VPWR VPWR sky130_fd_sc_hd__fill_2
XTAP_TAPCELL_ROW_51_934 VGND VPWR sky130_fd_sc_hd__tapvpwrvgnd_1
XFILLER_52_298 VGND VGND VPWR VPWR sky130_fd_sc_hd__decap_3
X_4918_ _4918_/A _4918_/B VGND VGND VPWR VPWR _4936_/B sky130_fd_sc_hd__nor2_2
Xclkbuf_leaf_32_clk clkload1/A VGND VGND VPWR VPWR _7355_/CLK sky130_fd_sc_hd__clkbuf_16
XFILLER_33_490 VGND VGND VPWR VPWR sky130_fd_sc_hd__decap_3
XFILLER_21_641 VGND VGND VPWR VPWR sky130_fd_sc_hd__decap_3
X_4849_ _4872_/A _4872_/B VGND VGND VPWR VPWR _4849_/Y sky130_fd_sc_hd__nor2_2
XFILLER_21_685 VGND VGND VPWR VPWR sky130_fd_sc_hd__decap_3
XFILLER_20_184 VGND VGND VPWR VPWR sky130_fd_sc_hd__decap_3
XFILLER_20_195 VGND VGND VPWR VPWR sky130_fd_sc_hd__fill_1
XFILLER_119_573 VGND VGND VPWR VPWR sky130_fd_sc_hd__decap_3
XFILLER_113_6 VGND VGND VPWR VPWR sky130_fd_sc_hd__decap_3
XFILLER_107_724 VGND VGND VPWR VPWR sky130_fd_sc_hd__decap_3
X_6519_ _6651_/A VGND VGND VPWR VPWR _6519_/Y sky130_fd_sc_hd__inv_2
XFILLER_106_212 VGND VGND VPWR VPWR sky130_fd_sc_hd__decap_3
XFILLER_4_339 VGND VGND VPWR VPWR sky130_fd_sc_hd__fill_2
XFILLER_106_256 VGND VGND VPWR VPWR sky130_fd_sc_hd__decap_3
XFILLER_122_716 VGND VGND VPWR VPWR sky130_fd_sc_hd__decap_3
XTAP_TAPCELL_ROW_95_1498 VGND VPWR sky130_fd_sc_hd__tapvpwrvgnd_1
XFILLER_79_107 VGND VGND VPWR VPWR sky130_fd_sc_hd__decap_3
XFILLER_106_289 VGND VGND VPWR VPWR sky130_fd_sc_hd__decap_3
XFILLER_0_545 VGND VGND VPWR VPWR sky130_fd_sc_hd__decap_3
XFILLER_88_663 VGND VGND VPWR VPWR sky130_fd_sc_hd__decap_3
XFILLER_87_140 VGND VGND VPWR VPWR sky130_fd_sc_hd__decap_3
XFILLER_0_567 VGND VGND VPWR VPWR sky130_fd_sc_hd__decap_3
XFILLER_88_696 VGND VGND VPWR VPWR sky130_fd_sc_hd__decap_3
XFILLER_48_527 VGND VGND VPWR VPWR sky130_fd_sc_hd__fill_2
XFILLER_102_473 VGND VGND VPWR VPWR sky130_fd_sc_hd__decap_3
XFILLER_0_589 VGND VGND VPWR VPWR sky130_fd_sc_hd__decap_3
XFILLER_63_508 VGND VGND VPWR VPWR sky130_fd_sc_hd__decap_3
XFILLER_28_251 VGND VGND VPWR VPWR sky130_fd_sc_hd__fill_1
XFILLER_28_262 VGND VGND VPWR VPWR sky130_fd_sc_hd__decap_3
XFILLER_44_722 VGND VGND VPWR VPWR sky130_fd_sc_hd__decap_3
XFILLER_113_72 VGND VGND VPWR VPWR sky130_fd_sc_hd__decap_3
XTAP_TAPCELL_ROW_39_780 VGND VPWR sky130_fd_sc_hd__tapvpwrvgnd_1
XFILLER_73_21 VGND VGND VPWR VPWR sky130_fd_sc_hd__decap_3
XFILLER_43_210 VGND VGND VPWR VPWR sky130_fd_sc_hd__decap_3
XFILLER_16_424 VGND VGND VPWR VPWR sky130_fd_sc_hd__fill_2
XFILLER_28_295 VGND VGND VPWR VPWR sky130_fd_sc_hd__decap_3
XFILLER_43_243 VGND VGND VPWR VPWR sky130_fd_sc_hd__decap_3
XFILLER_16_468 VGND VGND VPWR VPWR sky130_fd_sc_hd__decap_3
XFILLER_43_287 VGND VGND VPWR VPWR sky130_fd_sc_hd__decap_3
XFILLER_31_427 VGND VGND VPWR VPWR sky130_fd_sc_hd__decap_3
XFILLER_31_449 VGND VGND VPWR VPWR sky130_fd_sc_hd__decap_3
Xclkbuf_leaf_23_clk clkload3/A VGND VGND VPWR VPWR _7374_/CLK sky130_fd_sc_hd__clkbuf_16
XFILLER_8_601 VGND VGND VPWR VPWR sky130_fd_sc_hd__decap_3
XFILLER_12_663 VGND VGND VPWR VPWR sky130_fd_sc_hd__decap_3
XFILLER_8_634 VGND VGND VPWR VPWR sky130_fd_sc_hd__decap_3
XFILLER_11_162 VGND VGND VPWR VPWR sky130_fd_sc_hd__decap_3
XFILLER_8_645 VGND VGND VPWR VPWR sky130_fd_sc_hd__decap_3
XFILLER_78_9 VGND VGND VPWR VPWR sky130_fd_sc_hd__decap_3
XFILLER_12_696 VGND VGND VPWR VPWR sky130_fd_sc_hd__decap_3
XFILLER_8_678 VGND VGND VPWR VPWR sky130_fd_sc_hd__decap_3
XFILLER_7_166 VGND VGND VPWR VPWR sky130_fd_sc_hd__fill_2
XFILLER_22_91 VGND VGND VPWR VPWR sky130_fd_sc_hd__decap_3
XTAP_TAPCELL_ROW_59_1040 VGND VPWR sky130_fd_sc_hd__tapvpwrvgnd_1
XFILLER_98_405 VGND VGND VPWR VPWR sky130_fd_sc_hd__decap_3
XFILLER_98_427 VGND VGND VPWR VPWR sky130_fd_sc_hd__decap_3
XFILLER_113_727 VGND VGND VPWR VPWR sky130_fd_sc_hd__fill_1
XFILLER_79_641 VGND VGND VPWR VPWR sky130_fd_sc_hd__decap_3
XFILLER_112_248 VGND VGND VPWR VPWR sky130_fd_sc_hd__decap_3
XFILLER_39_505 VGND VGND VPWR VPWR sky130_fd_sc_hd__decap_3
XFILLER_79_685 VGND VGND VPWR VPWR sky130_fd_sc_hd__decap_3
XFILLER_78_162 VGND VGND VPWR VPWR sky130_fd_sc_hd__decap_3
XFILLER_66_302 VGND VGND VPWR VPWR sky130_fd_sc_hd__decap_3
XFILLER_94_622 VGND VGND VPWR VPWR sky130_fd_sc_hd__decap_3
XFILLER_66_324 VGND VGND VPWR VPWR sky130_fd_sc_hd__decap_3
XFILLER_66_346 VGND VGND VPWR VPWR sky130_fd_sc_hd__decap_3
XFILLER_94_666 VGND VGND VPWR VPWR sky130_fd_sc_hd__decap_3
XFILLER_66_357 VGND VGND VPWR VPWR sky130_fd_sc_hd__decap_3
XFILLER_66_368 VGND VGND VPWR VPWR sky130_fd_sc_hd__decap_3
XFILLER_19_240 VGND VGND VPWR VPWR sky130_fd_sc_hd__decap_3
XFILLER_94_699 VGND VGND VPWR VPWR sky130_fd_sc_hd__fill_1
XFILLER_35_700 VGND VGND VPWR VPWR sky130_fd_sc_hd__decap_3
XFILLER_81_316 VGND VGND VPWR VPWR sky130_fd_sc_hd__decap_3
XFILLER_93_187 VGND VGND VPWR VPWR sky130_fd_sc_hd__fill_1
XFILLER_34_210 VGND VGND VPWR VPWR sky130_fd_sc_hd__decap_3
X_6870_ _7378_/CLK _6870_/D VGND VGND VPWR VPWR _6870_/Q sky130_fd_sc_hd__dfxtp_2
XFILLER_19_295 VGND VGND VPWR VPWR sky130_fd_sc_hd__decap_3
XFILLER_62_563 VGND VGND VPWR VPWR sky130_fd_sc_hd__decap_3
XFILLER_34_265 VGND VGND VPWR VPWR sky130_fd_sc_hd__decap_3
XFILLER_22_405 VGND VGND VPWR VPWR sky130_fd_sc_hd__decap_3
XFILLER_50_725 VGND VGND VPWR VPWR sky130_fd_sc_hd__decap_3
XFILLER_62_596 VGND VGND VPWR VPWR sky130_fd_sc_hd__decap_3
XFILLER_22_427 VGND VGND VPWR VPWR sky130_fd_sc_hd__decap_3
XTAP_TAPCELL_ROW_17_485 VGND VPWR sky130_fd_sc_hd__tapvpwrvgnd_1
XFILLER_22_449 VGND VGND VPWR VPWR sky130_fd_sc_hd__decap_3
XFILLER_15_490 VGND VGND VPWR VPWR sky130_fd_sc_hd__decap_3
Xclkbuf_leaf_14_clk clkload2/A VGND VGND VPWR VPWR _7371_/CLK sky130_fd_sc_hd__clkbuf_16
X_4703_ _6992_/Q _6993_/Q _5001_/A VGND VGND VPWR VPWR _4977_/A sky130_fd_sc_hd__and3_2
XFILLER_8_60 VGND VGND VPWR VPWR sky130_fd_sc_hd__fill_1
X_4634_ _4937_/A _4920_/A _4967_/B _4950_/A VGND VGND VPWR VPWR _4634_/Y sky130_fd_sc_hd__nand4bb_2
X_4565_ _4565_/A _4577_/B VGND VGND VPWR VPWR _7298_/D sky130_fd_sc_hd__and2_2
Xhold601 _6724_/Q VGND VGND VPWR VPWR _6724_/D sky130_fd_sc_hd__dlygate4sd3_1
X_7353_ _7356_/CLK _7353_/D _6633_/Y VGND VGND VPWR VPWR _7353_/Q sky130_fd_sc_hd__dfrtp_2
XFILLER_116_521 VGND VGND VPWR VPWR sky130_fd_sc_hd__decap_3
Xhold612 _6859_/Q VGND VGND VPWR VPWR _6859_/D sky130_fd_sc_hd__dlygate4sd3_1
Xhold623 _6792_/Q VGND VGND VPWR VPWR _6792_/D sky130_fd_sc_hd__dlygate4sd3_1
X_6304_ _6651_/A VGND VGND VPWR VPWR _6304_/Y sky130_fd_sc_hd__inv_2
Xhold634 _6952_/Q VGND VGND VPWR VPWR _6952_/D sky130_fd_sc_hd__dlygate4sd3_1
XFILLER_116_554 VGND VGND VPWR VPWR sky130_fd_sc_hd__decap_3
X_3516_ _5118_/A _5129_/B _5118_/D _3371_/A VGND VGND VPWR VPWR _3516_/X sky130_fd_sc_hd__a211o_2
Xhold645 _6897_/Q VGND VGND VPWR VPWR _6897_/D sky130_fd_sc_hd__dlygate4sd3_1
XFILLER_89_405 VGND VGND VPWR VPWR sky130_fd_sc_hd__decap_3
Xhold656 _6936_/Q VGND VGND VPWR VPWR _6936_/D sky130_fd_sc_hd__dlygate4sd3_1
X_7284_ _7313_/CLK _7284_/D _6564_/Y VGND VGND VPWR VPWR _7284_/Q sky130_fd_sc_hd__dfrtp_2
XFILLER_104_716 VGND VGND VPWR VPWR sky130_fd_sc_hd__decap_3
Xhold667 _6736_/Q VGND VGND VPWR VPWR _6736_/D sky130_fd_sc_hd__dlygate4sd3_1
XFILLER_116_587 VGND VGND VPWR VPWR sky130_fd_sc_hd__fill_1
XPHY_EDGE_ROW_4_Right_4 VGND VGND VPWR VPWR sky130_fd_sc_hd__decap_3
Xhold678 _6734_/Q VGND VGND VPWR VPWR _6734_/D sky130_fd_sc_hd__dlygate4sd3_1
XFILLER_116_598 VGND VGND VPWR VPWR sky130_fd_sc_hd__decap_3
X_3447_ _7090_/Q _4335_/B1 _4351_/B1 _7122_/Q VGND VGND VPWR VPWR _3447_/X sky130_fd_sc_hd__a22o_2
Xhold689 _6871_/Q VGND VGND VPWR VPWR _6871_/D sky130_fd_sc_hd__dlygate4sd3_1
XFILLER_89_449 VGND VGND VPWR VPWR sky130_fd_sc_hd__decap_3
XFILLER_69_140 VGND VGND VPWR VPWR sky130_fd_sc_hd__fill_1
X_3378_ _3378_/A _5646_/A VGND VGND VPWR VPWR _5229_/C sky130_fd_sc_hd__nor2_2
XFILLER_85_600 VGND VGND VPWR VPWR sky130_fd_sc_hd__decap_3
X_5117_ _5595_/B _5658_/D _3896_/Y VGND VGND VPWR VPWR _5117_/X sky130_fd_sc_hd__or3b_2
XFILLER_69_184 VGND VGND VPWR VPWR sky130_fd_sc_hd__decap_3
XFILLER_85_644 VGND VGND VPWR VPWR sky130_fd_sc_hd__decap_3
XFILLER_111_281 VGND VGND VPWR VPWR sky130_fd_sc_hd__decap_3
X_5048_ _5086_/A _5084_/B _4621_/X VGND VGND VPWR VPWR _5073_/B sky130_fd_sc_hd__o21bai_2
XFILLER_85_688 VGND VGND VPWR VPWR sky130_fd_sc_hd__decap_3
XFILLER_26_722 VGND VGND VPWR VPWR sky130_fd_sc_hd__decap_3
XFILLER_27_69 VGND VGND VPWR VPWR sky130_fd_sc_hd__decap_3
XFILLER_41_703 VGND VGND VPWR VPWR sky130_fd_sc_hd__decap_3
XFILLER_13_405 VGND VGND VPWR VPWR sky130_fd_sc_hd__decap_3
XFILLER_25_276 VGND VGND VPWR VPWR sky130_fd_sc_hd__decap_3
X_6999_ _7370_/CLK _6999_/D _6279_/Y VGND VGND VPWR VPWR _6999_/Q sky130_fd_sc_hd__dfrtp_2
XFILLER_25_287 VGND VGND VPWR VPWR sky130_fd_sc_hd__decap_3
XFILLER_40_213 VGND VGND VPWR VPWR sky130_fd_sc_hd__fill_1
XFILLER_40_235 VGND VGND VPWR VPWR sky130_fd_sc_hd__decap_3
XFILLER_13_449 VGND VGND VPWR VPWR sky130_fd_sc_hd__decap_3
XFILLER_40_279 VGND VGND VPWR VPWR sky130_fd_sc_hd__fill_2
XTAP_TAPCELL_ROW_97_1527 VGND VPWR sky130_fd_sc_hd__tapvpwrvgnd_1
XFILLER_5_615 VGND VGND VPWR VPWR sky130_fd_sc_hd__fill_1
XFILLER_5_626 VGND VGND VPWR VPWR sky130_fd_sc_hd__decap_3
XFILLER_111_3 VGND VGND VPWR VPWR sky130_fd_sc_hd__decap_3
XFILLER_107_532 VGND VGND VPWR VPWR sky130_fd_sc_hd__decap_3
XFILLER_5_659 VGND VGND VPWR VPWR sky130_fd_sc_hd__decap_3
XFILLER_107_576 VGND VGND VPWR VPWR sky130_fd_sc_hd__decap_3
XFILLER_4_29 VGND VGND VPWR VPWR sky130_fd_sc_hd__decap_3
XFILLER_108_50 VGND VGND VPWR VPWR sky130_fd_sc_hd__fill_2
XFILLER_122_513 VGND VGND VPWR VPWR sky130_fd_sc_hd__decap_3
XFILLER_108_61 VGND VGND VPWR VPWR sky130_fd_sc_hd__decap_3
XFILLER_68_32 VGND VGND VPWR VPWR sky130_fd_sc_hd__decap_3
XFILLER_0_320 VGND VGND VPWR VPWR sky130_fd_sc_hd__decap_3
XFILLER_122_557 VGND VGND VPWR VPWR sky130_fd_sc_hd__decap_3
XFILLER_95_408 VGND VGND VPWR VPWR sky130_fd_sc_hd__decap_3
XFILLER_110_719 VGND VGND VPWR VPWR sky130_fd_sc_hd__decap_3
XFILLER_76_622 VGND VGND VPWR VPWR sky130_fd_sc_hd__decap_3
XFILLER_48_324 VGND VGND VPWR VPWR sky130_fd_sc_hd__decap_3
XFILLER_102_292 VGND VGND VPWR VPWR sky130_fd_sc_hd__decap_3
XFILLER_76_666 VGND VGND VPWR VPWR sky130_fd_sc_hd__decap_3
XFILLER_48_357 VGND VGND VPWR VPWR sky130_fd_sc_hd__decap_3
XFILLER_91_603 VGND VGND VPWR VPWR sky130_fd_sc_hd__decap_3
XFILLER_75_165 VGND VGND VPWR VPWR sky130_fd_sc_hd__decap_3
XFILLER_63_305 VGND VGND VPWR VPWR sky130_fd_sc_hd__decap_3
XFILLER_17_700 VGND VGND VPWR VPWR sky130_fd_sc_hd__decap_3
XFILLER_76_699 VGND VGND VPWR VPWR sky130_fd_sc_hd__fill_1
XFILLER_90_102 VGND VGND VPWR VPWR sky130_fd_sc_hd__decap_3
XFILLER_29_571 VGND VGND VPWR VPWR sky130_fd_sc_hd__decap_3
Xplace305 _3651_/Y VGND VGND VPWR VPWR _3840_/A2 sky130_fd_sc_hd__buf_2
XFILLER_91_647 VGND VGND VPWR VPWR sky130_fd_sc_hd__decap_3
XFILLER_16_210 VGND VGND VPWR VPWR sky130_fd_sc_hd__decap_3
Xplace316 _5020_/A VGND VGND VPWR VPWR _4814_/A sky130_fd_sc_hd__buf_2
XFILLER_63_349 VGND VGND VPWR VPWR sky130_fd_sc_hd__decap_3
Xplace327 _4601_/S VGND VGND VPWR VPWR _4356_/A2 sky130_fd_sc_hd__buf_2
XFILLER_56_390 VGND VGND VPWR VPWR sky130_fd_sc_hd__decap_3
XTAP_TAPCELL_ROW_106_1645 VGND VPWR sky130_fd_sc_hd__tapvpwrvgnd_1
XFILLER_44_541 VGND VGND VPWR VPWR sky130_fd_sc_hd__decap_3
XTAP_TAPCELL_ROW_34_709 VGND VPWR sky130_fd_sc_hd__tapvpwrvgnd_1
Xplace338 _3407_/X VGND VGND VPWR VPWR _4351_/B1 sky130_fd_sc_hd__buf_2
XFILLER_16_243 VGND VGND VPWR VPWR sky130_fd_sc_hd__decap_3
Xplace349 _3521_/Y VGND VGND VPWR VPWR _4764_/B sky130_fd_sc_hd__buf_2
XFILLER_32_725 VGND VGND VPWR VPWR sky130_fd_sc_hd__decap_3
XFILLER_31_202 VGND VGND VPWR VPWR sky130_fd_sc_hd__decap_3
XFILLER_16_287 VGND VGND VPWR VPWR sky130_fd_sc_hd__decap_3
XFILLER_31_246 VGND VGND VPWR VPWR sky130_fd_sc_hd__decap_3
XTAP_TAPCELL_ROW_14_444 VGND VPWR sky130_fd_sc_hd__tapvpwrvgnd_1
XTAP_TAPCELL_ROW_14_455 VGND VPWR sky130_fd_sc_hd__tapvpwrvgnd_1
XFILLER_12_471 VGND VGND VPWR VPWR sky130_fd_sc_hd__decap_3
XFILLER_8_453 VGND VGND VPWR VPWR sky130_fd_sc_hd__decap_3
XFILLER_8_464 VGND VGND VPWR VPWR sky130_fd_sc_hd__decap_3
XFILLER_99_703 VGND VGND VPWR VPWR sky130_fd_sc_hd__decap_3
X_4350_ _7065_/Q _4305_/B _4205_/A VGND VGND VPWR VPWR _4367_/B sky130_fd_sc_hd__o21a_2
XTAP_TAPCELL_ROW_117_1785 VGND VPWR sky130_fd_sc_hd__tapvpwrvgnd_1
X_3301_ _6981_/Q _3327_/B VGND VGND VPWR VPWR _3519_/B sky130_fd_sc_hd__nand2_4
XFILLER_4_681 VGND VGND VPWR VPWR sky130_fd_sc_hd__decap_3
X_4281_ _7254_/Q _3358_/X _4278_/X _4280_/X VGND VGND VPWR VPWR _4281_/X sky130_fd_sc_hd__a211o_2
XFILLER_113_535 VGND VGND VPWR VPWR sky130_fd_sc_hd__decap_3
XFILLER_113_579 VGND VGND VPWR VPWR sky130_fd_sc_hd__decap_3
Xclkbuf_leaf_3_clk clkload0/A VGND VGND VPWR VPWR clkload8/A sky130_fd_sc_hd__clkbuf_16
XFILLER_67_600 VGND VGND VPWR VPWR sky130_fd_sc_hd__decap_3
XFILLER_100_218 VGND VGND VPWR VPWR sky130_fd_sc_hd__decap_3
XFILLER_67_644 VGND VGND VPWR VPWR sky130_fd_sc_hd__decap_3
XFILLER_39_335 VGND VGND VPWR VPWR sky130_fd_sc_hd__fill_1
XFILLER_94_430 VGND VGND VPWR VPWR sky130_fd_sc_hd__decap_3
XFILLER_39_357 VGND VGND VPWR VPWR sky130_fd_sc_hd__decap_3
XFILLER_27_508 VGND VGND VPWR VPWR sky130_fd_sc_hd__decap_3
XFILLER_67_688 VGND VGND VPWR VPWR sky130_fd_sc_hd__decap_3
XFILLER_94_474 VGND VGND VPWR VPWR sky130_fd_sc_hd__fill_2
XFILLER_82_625 VGND VGND VPWR VPWR sky130_fd_sc_hd__decap_3
XFILLER_81_113 VGND VGND VPWR VPWR sky130_fd_sc_hd__fill_2
XFILLER_54_327 VGND VGND VPWR VPWR sky130_fd_sc_hd__decap_3
XFILLER_81_124 VGND VGND VPWR VPWR sky130_fd_sc_hd__decap_3
X_6922_ _7378_/CLK _6922_/D VGND VGND VPWR VPWR _6922_/Q sky130_fd_sc_hd__dfxtp_2
XFILLER_82_669 VGND VGND VPWR VPWR sky130_fd_sc_hd__decap_3
XFILLER_23_703 VGND VGND VPWR VPWR sky130_fd_sc_hd__decap_3
X_6853_ clkload7/A _6853_/D VGND VGND VPWR VPWR _6853_/Q sky130_fd_sc_hd__dfxtp_2
XFILLER_62_360 VGND VGND VPWR VPWR sky130_fd_sc_hd__decap_3
XFILLER_120_29 VGND VGND VPWR VPWR sky130_fd_sc_hd__decap_3
XTAP_TAPCELL_ROW_81_1317 VGND VPWR sky130_fd_sc_hd__tapvpwrvgnd_1
XFILLER_35_585 VGND VGND VPWR VPWR sky130_fd_sc_hd__decap_3
XFILLER_22_213 VGND VGND VPWR VPWR sky130_fd_sc_hd__decap_3
Xfanout28 _6603_/A VGND VGND VPWR VPWR _6598_/A sky130_fd_sc_hd__clkdlybuf4s25_1
Xfanout39 _6570_/A VGND VGND VPWR VPWR _6602_/A sky130_fd_sc_hd__buf_2
XFILLER_22_235 VGND VGND VPWR VPWR sky130_fd_sc_hd__decap_3
X_6784_ _7215_/CLK _6784_/D VGND VGND VPWR VPWR _6784_/Q sky130_fd_sc_hd__dfxtp_2
X_3996_ _7344_/Q _4534_/A0 _3996_/S VGND VGND VPWR VPWR _7344_/D sky130_fd_sc_hd__mux2_2
XFILLER_50_577 VGND VGND VPWR VPWR sky130_fd_sc_hd__fill_1
XFILLER_22_268 VGND VGND VPWR VPWR sky130_fd_sc_hd__decap_3
XFILLER_10_419 VGND VGND VPWR VPWR sky130_fd_sc_hd__fill_1
X_5735_ _7373_/Q hold926/X _5735_/S VGND VGND VPWR VPWR _6717_/D sky130_fd_sc_hd__mux2_2
X_5666_ _5666_/A _5666_/B VGND VGND VPWR VPWR _5668_/B sky130_fd_sc_hd__or2_2
XFILLER_108_307 VGND VGND VPWR VPWR sky130_fd_sc_hd__fill_1
X_7405_ _7405_/CLK _7405_/D _6685_/Y VGND VGND VPWR VPWR _7405_/Q sky130_fd_sc_hd__dfrtp_2
X_4617_ _5114_/B _4617_/B _4617_/C VGND VGND VPWR VPWR _5099_/A sky130_fd_sc_hd__or3_4
X_5597_ hold940/X _5587_/B _5154_/Y VGND VGND VPWR VPWR _7029_/D sky130_fd_sc_hd__a21o_2
X_7336_ _7374_/CLK _7336_/D _6616_/Y VGND VGND VPWR VPWR _7336_/Q sky130_fd_sc_hd__dfrtp_2
X_4548_ _4548_/A _4559_/B VGND VGND VPWR VPWR _7306_/D sky130_fd_sc_hd__and2_2
XFILLER_2_629 VGND VGND VPWR VPWR sky130_fd_sc_hd__decap_3
XFILLER_89_213 VGND VGND VPWR VPWR sky130_fd_sc_hd__decap_3
XTAP_TAPCELL_ROW_92_1457 VGND VPWR sky130_fd_sc_hd__tapvpwrvgnd_1
XTAP_TAPCELL_ROW_92_1468 VGND VPWR sky130_fd_sc_hd__tapvpwrvgnd_1
X_7267_ _7395_/CLK _7267_/D _6547_/Y VGND VGND VPWR VPWR _7267_/Q sky130_fd_sc_hd__dfrtp_2
XFILLER_89_246 VGND VGND VPWR VPWR sky130_fd_sc_hd__decap_3
XFILLER_104_557 VGND VGND VPWR VPWR sky130_fd_sc_hd__decap_3
XFILLER_89_279 VGND VGND VPWR VPWR sky130_fd_sc_hd__fill_1
X_7198_ _7392_/CLK _7198_/D _6478_/Y VGND VGND VPWR VPWR _7198_/Q sky130_fd_sc_hd__dfrtp_2
XFILLER_58_611 VGND VGND VPWR VPWR sky130_fd_sc_hd__decap_3
Xhold1120 _7231_/Q VGND VGND VPWR VPWR _5194_/A sky130_fd_sc_hd__dlygate4sd3_1
XFILLER_97_290 VGND VGND VPWR VPWR sky130_fd_sc_hd__decap_3
XFILLER_85_441 VGND VGND VPWR VPWR sky130_fd_sc_hd__decap_3
Xhold1131 _7162_/Q VGND VGND VPWR VPWR _5338_/A0 sky130_fd_sc_hd__dlygate4sd3_1
XFILLER_58_666 VGND VGND VPWR VPWR sky130_fd_sc_hd__decap_3
Xhold1142 _7339_/Q VGND VGND VPWR VPWR _4480_/A0 sky130_fd_sc_hd__dlygate4sd3_1
Xhold1153 _7319_/Q VGND VGND VPWR VPWR _4520_/A0 sky130_fd_sc_hd__dlygate4sd3_1
Xhold1164 _7145_/Q VGND VGND VPWR VPWR _5375_/A0 sky130_fd_sc_hd__dlygate4sd3_1
XFILLER_85_474 VGND VGND VPWR VPWR sky130_fd_sc_hd__decap_3
XFILLER_73_614 VGND VGND VPWR VPWR sky130_fd_sc_hd__fill_2
XFILLER_45_305 VGND VGND VPWR VPWR sky130_fd_sc_hd__decap_3
XFILLER_58_699 VGND VGND VPWR VPWR sky130_fd_sc_hd__fill_1
XFILLER_57_176 VGND VGND VPWR VPWR sky130_fd_sc_hd__decap_3
XPHY_EDGE_ROW_79_Right_79 VGND VGND VPWR VPWR sky130_fd_sc_hd__decap_3
Xhold1175 _7180_/Q VGND VGND VPWR VPWR _5300_/A0 sky130_fd_sc_hd__dlygate4sd3_1
XFILLER_45_327 VGND VGND VPWR VPWR sky130_fd_sc_hd__fill_1
Xhold1186 _7156_/Q VGND VGND VPWR VPWR _5350_/A0 sky130_fd_sc_hd__dlygate4sd3_1
XFILLER_73_647 VGND VGND VPWR VPWR sky130_fd_sc_hd__decap_3
Xhold1197 _7009_/Q VGND VGND VPWR VPWR _7009_/D sky130_fd_sc_hd__dlygate4sd3_1
XFILLER_72_124 VGND VGND VPWR VPWR sky130_fd_sc_hd__decap_3
XFILLER_38_390 VGND VGND VPWR VPWR sky130_fd_sc_hd__decap_3
XFILLER_26_552 VGND VGND VPWR VPWR sky130_fd_sc_hd__fill_1
XFILLER_72_168 VGND VGND VPWR VPWR sky130_fd_sc_hd__decap_3
XFILLER_41_500 VGND VGND VPWR VPWR sky130_fd_sc_hd__decap_3
XFILLER_26_574 VGND VGND VPWR VPWR sky130_fd_sc_hd__decap_3
XFILLER_41_511 VGND VGND VPWR VPWR sky130_fd_sc_hd__fill_1
XFILLER_14_725 VGND VGND VPWR VPWR sky130_fd_sc_hd__decap_3
XFILLER_13_202 VGND VGND VPWR VPWR sky130_fd_sc_hd__decap_3
XFILLER_81_691 VGND VGND VPWR VPWR sky130_fd_sc_hd__decap_3
XFILLER_13_246 VGND VGND VPWR VPWR sky130_fd_sc_hd__decap_3
XFILLER_110_62 VGND VGND VPWR VPWR sky130_fd_sc_hd__decap_3
XFILLER_9_239 VGND VGND VPWR VPWR sky130_fd_sc_hd__decap_3
XTAP_TAPCELL_ROW_101_1575 VGND VPWR sky130_fd_sc_hd__tapvpwrvgnd_1
XTAP_TAPCELL_ROW_11_414 VGND VPWR sky130_fd_sc_hd__tapvpwrvgnd_1
XTAP_TAPCELL_ROW_101_1586 VGND VPWR sky130_fd_sc_hd__tapvpwrvgnd_1
XFILLER_70_66 VGND VGND VPWR VPWR sky130_fd_sc_hd__fill_1
XPHY_EDGE_ROW_88_Right_88 VGND VGND VPWR VPWR sky130_fd_sc_hd__decap_3
XFILLER_5_445 VGND VGND VPWR VPWR sky130_fd_sc_hd__decap_3
XFILLER_119_60 VGND VGND VPWR VPWR sky130_fd_sc_hd__decap_3
XFILLER_119_93 VGND VGND VPWR VPWR sky130_fd_sc_hd__decap_3
XFILLER_79_75 VGND VGND VPWR VPWR sky130_fd_sc_hd__decap_3
XFILLER_96_728 VGND VGND VPWR VPWR sky130_fd_sc_hd__decap_3
XFILLER_95_205 VGND VGND VPWR VPWR sky130_fd_sc_hd__decap_3
XFILLER_1_662 VGND VGND VPWR VPWR sky130_fd_sc_hd__decap_3
XFILLER_1_673 VGND VGND VPWR VPWR sky130_fd_sc_hd__decap_3
XFILLER_110_527 VGND VGND VPWR VPWR sky130_fd_sc_hd__decap_3
XFILLER_0_161 VGND VGND VPWR VPWR sky130_fd_sc_hd__decap_3
XFILLER_0_183 VGND VGND VPWR VPWR sky130_fd_sc_hd__decap_3
XFILLER_49_644 VGND VGND VPWR VPWR sky130_fd_sc_hd__decap_3
XPHY_EDGE_ROW_97_Right_97 VGND VGND VPWR VPWR sky130_fd_sc_hd__decap_3
XFILLER_48_154 VGND VGND VPWR VPWR sky130_fd_sc_hd__decap_3
XFILLER_95_96 VGND VGND VPWR VPWR sky130_fd_sc_hd__decap_3
XFILLER_76_474 VGND VGND VPWR VPWR sky130_fd_sc_hd__fill_2
XFILLER_49_688 VGND VGND VPWR VPWR sky130_fd_sc_hd__decap_3
XFILLER_64_625 VGND VGND VPWR VPWR sky130_fd_sc_hd__decap_3
XTAP_TAPCELL_ROW_19_514 VGND VPWR sky130_fd_sc_hd__tapvpwrvgnd_1
XFILLER_36_327 VGND VGND VPWR VPWR sky130_fd_sc_hd__decap_3
XFILLER_63_113 VGND VGND VPWR VPWR sky130_fd_sc_hd__decap_3
XFILLER_91_444 VGND VGND VPWR VPWR sky130_fd_sc_hd__decap_3
XFILLER_63_135 VGND VGND VPWR VPWR sky130_fd_sc_hd__decap_3
XFILLER_91_455 VGND VGND VPWR VPWR sky130_fd_sc_hd__decap_3
XFILLER_64_669 VGND VGND VPWR VPWR sky130_fd_sc_hd__decap_3
Xplace113 _3665_/B VGND VGND VPWR VPWR place113/X sky130_fd_sc_hd__buf_2
XTAP_TAPCELL_ROW_47_878 VGND VPWR sky130_fd_sc_hd__tapvpwrvgnd_1
XFILLER_91_499 VGND VGND VPWR VPWR sky130_fd_sc_hd__decap_3
XFILLER_44_371 VGND VGND VPWR VPWR sky130_fd_sc_hd__decap_3
XFILLER_17_585 VGND VGND VPWR VPWR sky130_fd_sc_hd__decap_3
XFILLER_32_522 VGND VGND VPWR VPWR sky130_fd_sc_hd__fill_1
XFILLER_32_533 VGND VGND VPWR VPWR sky130_fd_sc_hd__fill_1
X_3850_ _6810_/Q _3893_/B1 _3850_/B1 _6820_/Q VGND VGND VPWR VPWR _3850_/X sky130_fd_sc_hd__a22o_2
XFILLER_32_577 VGND VGND VPWR VPWR sky130_fd_sc_hd__decap_3
XFILLER_20_728 VGND VGND VPWR VPWR sky130_fd_sc_hd__decap_3
X_3781_ _6949_/Q _3893_/B1 _3850_/B1 _6961_/Q _3780_/X VGND VGND VPWR VPWR _3781_/X
+ sky130_fd_sc_hd__a221o_2
XTAP_TAPCELL_ROW_119_1814 VGND VPWR sky130_fd_sc_hd__tapvpwrvgnd_1
XFILLER_74_3 VGND VGND VPWR VPWR sky130_fd_sc_hd__decap_3
XFILLER_118_616 VGND VGND VPWR VPWR sky130_fd_sc_hd__decap_3
XFILLER_8_283 VGND VGND VPWR VPWR sky130_fd_sc_hd__fill_1
X_4402_ _7082_/Q _4102_/B _4432_/B1 _4401_/X VGND VGND VPWR VPWR _4403_/A sky130_fd_sc_hd__o211a_2
Xoutput503 _3417_/C VGND VGND VPWR VPWR instruction_out[21] sky130_fd_sc_hd__clkdlybuf4s25_1
Xoutput514 _5640_/Y VGND VGND VPWR VPWR instruction_out[4] sky130_fd_sc_hd__clkdlybuf4s25_1
Xoutput525 _6991_/Q VGND VGND VPWR VPWR pc_out[14] sky130_fd_sc_hd__clkdlybuf4s25_1
XFILLER_99_511 VGND VGND VPWR VPWR sky130_fd_sc_hd__decap_3
Xoutput536 _7001_/Q VGND VGND VPWR VPWR pc_out[24] sky130_fd_sc_hd__clkdlybuf4s25_1
Xoutput547 _3340_/A VGND VGND VPWR VPWR pc_out[5] sky130_fd_sc_hd__clkdlybuf4s25_1
X_7121_ _7313_/CLK _7121_/D _6401_/Y VGND VGND VPWR VPWR _7121_/Q sky130_fd_sc_hd__dfrtp_2
X_4333_ _7127_/Q _4351_/B1 _4332_/X VGND VGND VPWR VPWR _4336_/A sky130_fd_sc_hd__a21o_2
XFILLER_87_706 VGND VGND VPWR VPWR sky130_fd_sc_hd__decap_3
XFILLER_113_343 VGND VGND VPWR VPWR sky130_fd_sc_hd__fill_1
XFILLER_59_408 VGND VGND VPWR VPWR sky130_fd_sc_hd__decap_3
X_4264_ _4264_/A _4264_/B VGND VGND VPWR VPWR _4376_/B sky130_fd_sc_hd__nor2_2
X_7052_ _7406_/CLK _7052_/D _6332_/Y VGND VGND VPWR VPWR _7052_/Q sky130_fd_sc_hd__dfrtp_2
XFILLER_99_588 VGND VGND VPWR VPWR sky130_fd_sc_hd__decap_3
XFILLER_113_365 VGND VGND VPWR VPWR sky130_fd_sc_hd__fill_1
XFILLER_86_227 VGND VGND VPWR VPWR sky130_fd_sc_hd__decap_3
XFILLER_101_549 VGND VGND VPWR VPWR sky130_fd_sc_hd__decap_3
X_4195_ _7135_/Q _4267_/A2 _4267_/B1 _7167_/Q VGND VGND VPWR VPWR _4195_/X sky130_fd_sc_hd__a22o_2
XFILLER_39_121 VGND VGND VPWR VPWR sky130_fd_sc_hd__decap_3
XFILLER_55_603 VGND VGND VPWR VPWR sky130_fd_sc_hd__decap_3
XFILLER_82_400 VGND VGND VPWR VPWR sky130_fd_sc_hd__decap_3
XFILLER_67_485 VGND VGND VPWR VPWR sky130_fd_sc_hd__decap_3
XFILLER_94_282 VGND VGND VPWR VPWR sky130_fd_sc_hd__decap_3
XFILLER_55_647 VGND VGND VPWR VPWR sky130_fd_sc_hd__decap_3
XFILLER_27_349 VGND VGND VPWR VPWR sky130_fd_sc_hd__decap_3
XFILLER_82_455 VGND VGND VPWR VPWR sky130_fd_sc_hd__decap_3
XFILLER_82_477 VGND VGND VPWR VPWR sky130_fd_sc_hd__decap_3
X_6905_ clkload9/A _6905_/D VGND VGND VPWR VPWR _6905_/Q sky130_fd_sc_hd__dfxtp_2
XFILLER_70_628 VGND VGND VPWR VPWR sky130_fd_sc_hd__decap_3
XFILLER_63_691 VGND VGND VPWR VPWR sky130_fd_sc_hd__decap_3
XFILLER_35_393 VGND VGND VPWR VPWR sky130_fd_sc_hd__decap_3
X_6836_ clkload4/A _6836_/D VGND VGND VPWR VPWR _6836_/Q sky130_fd_sc_hd__dfxtp_2
XFILLER_50_330 VGND VGND VPWR VPWR sky130_fd_sc_hd__decap_3
XFILLER_11_706 VGND VGND VPWR VPWR sky130_fd_sc_hd__decap_3
XFILLER_23_577 VGND VGND VPWR VPWR sky130_fd_sc_hd__decap_3
XFILLER_50_363 VGND VGND VPWR VPWR sky130_fd_sc_hd__fill_1
X_6767_ _7380_/CLK _6767_/D VGND VGND VPWR VPWR _6767_/Q sky130_fd_sc_hd__dfxtp_2
X_3979_ _7351_/Q _4520_/A0 _3989_/S VGND VGND VPWR VPWR _7351_/D sky130_fd_sc_hd__mux2_2
XFILLER_10_238 VGND VGND VPWR VPWR sky130_fd_sc_hd__decap_3
XFILLER_6_209 VGND VGND VPWR VPWR sky130_fd_sc_hd__decap_3
X_6698_ _7386_/CLK _6698_/D VGND VGND VPWR VPWR _6698_/Q sky130_fd_sc_hd__dfxtp_2
XFILLER_108_104 VGND VGND VPWR VPWR sky130_fd_sc_hd__decap_3
XFILLER_40_25 VGND VGND VPWR VPWR sky130_fd_sc_hd__decap_3
XFILLER_109_638 VGND VGND VPWR VPWR sky130_fd_sc_hd__decap_3
X_5649_ _5649_/A VGND VGND VPWR VPWR _5649_/X sky130_fd_sc_hd__buf_1
XFILLER_108_159 VGND VGND VPWR VPWR sky130_fd_sc_hd__decap_3
XFILLER_123_107 VGND VGND VPWR VPWR sky130_fd_sc_hd__decap_3
XFILLER_117_671 VGND VGND VPWR VPWR sky130_fd_sc_hd__fill_1
XFILLER_117_682 VGND VGND VPWR VPWR sky130_fd_sc_hd__decap_3
X_7319_ _7355_/CLK _7319_/D _6599_/Y VGND VGND VPWR VPWR _7319_/Q sky130_fd_sc_hd__dfrtp_2
XFILLER_6_6 VGND VGND VPWR VPWR sky130_fd_sc_hd__fill_2
XFILLER_104_321 VGND VGND VPWR VPWR sky130_fd_sc_hd__decap_3
XFILLER_49_34 VGND VGND VPWR VPWR sky130_fd_sc_hd__decap_3
XFILLER_78_728 VGND VGND VPWR VPWR sky130_fd_sc_hd__decap_3
XFILLER_77_205 VGND VGND VPWR VPWR sky130_fd_sc_hd__decap_3
XFILLER_104_365 VGND VGND VPWR VPWR sky130_fd_sc_hd__decap_3
XFILLER_93_709 VGND VGND VPWR VPWR sky130_fd_sc_hd__decap_3
XFILLER_58_430 VGND VGND VPWR VPWR sky130_fd_sc_hd__decap_3
XFILLER_92_208 VGND VGND VPWR VPWR sky130_fd_sc_hd__decap_3
XFILLER_58_474 VGND VGND VPWR VPWR sky130_fd_sc_hd__fill_2
XFILLER_46_614 VGND VGND VPWR VPWR sky130_fd_sc_hd__decap_3
XFILLER_18_305 VGND VGND VPWR VPWR sky130_fd_sc_hd__decap_3
XFILLER_85_271 VGND VGND VPWR VPWR sky130_fd_sc_hd__decap_3
XFILLER_100_571 VGND VGND VPWR VPWR sky130_fd_sc_hd__decap_3
XFILLER_45_113 VGND VGND VPWR VPWR sky130_fd_sc_hd__decap_3
XFILLER_85_293 VGND VGND VPWR VPWR sky130_fd_sc_hd__decap_3
XFILLER_65_55 VGND VGND VPWR VPWR sky130_fd_sc_hd__fill_1
XFILLER_18_349 VGND VGND VPWR VPWR sky130_fd_sc_hd__decap_3
XFILLER_65_66 VGND VGND VPWR VPWR sky130_fd_sc_hd__decap_3
XFILLER_46_669 VGND VGND VPWR VPWR sky130_fd_sc_hd__decap_3
XFILLER_73_466 VGND VGND VPWR VPWR sky130_fd_sc_hd__decap_3
XFILLER_61_617 VGND VGND VPWR VPWR sky130_fd_sc_hd__decap_3
XTAP_TAPCELL_ROW_103_1604 VGND VPWR sky130_fd_sc_hd__tapvpwrvgnd_1
XFILLER_73_488 VGND VGND VPWR VPWR sky130_fd_sc_hd__fill_2
XFILLER_33_319 VGND VGND VPWR VPWR sky130_fd_sc_hd__decap_3
XFILLER_26_360 VGND VGND VPWR VPWR sky130_fd_sc_hd__decap_3
XFILLER_73_499 VGND VGND VPWR VPWR sky130_fd_sc_hd__fill_1
XTAP_TAPCELL_ROW_44_837 VGND VPWR sky130_fd_sc_hd__tapvpwrvgnd_1
XFILLER_60_127 VGND VGND VPWR VPWR sky130_fd_sc_hd__decap_3
XFILLER_26_371 VGND VGND VPWR VPWR sky130_fd_sc_hd__decap_3
XFILLER_14_533 VGND VGND VPWR VPWR sky130_fd_sc_hd__fill_1
XFILLER_121_72 VGND VGND VPWR VPWR sky130_fd_sc_hd__decap_3
XFILLER_53_190 VGND VGND VPWR VPWR sky130_fd_sc_hd__decap_3
XFILLER_14_555 VGND VGND VPWR VPWR sky130_fd_sc_hd__decap_3
XFILLER_81_65 VGND VGND VPWR VPWR sky130_fd_sc_hd__decap_3
XFILLER_41_363 VGND VGND VPWR VPWR sky130_fd_sc_hd__decap_3
XTAP_TAPCELL_ROW_24_583 VGND VPWR sky130_fd_sc_hd__tapvpwrvgnd_1
XFILLER_6_710 VGND VGND VPWR VPWR sky130_fd_sc_hd__decap_3
XFILLER_108_660 VGND VGND VPWR VPWR sky130_fd_sc_hd__decap_3
XTAP_TAPCELL_ROW_114_1744 VGND VPWR sky130_fd_sc_hd__tapvpwrvgnd_1
XFILLER_108_693 VGND VGND VPWR VPWR sky130_fd_sc_hd__decap_3
XFILLER_30_91 VGND VGND VPWR VPWR sky130_fd_sc_hd__decap_3
XTAP_TAPCELL_ROW_114_1755 VGND VPWR sky130_fd_sc_hd__tapvpwrvgnd_1
XFILLER_107_181 VGND VGND VPWR VPWR sky130_fd_sc_hd__decap_3
XFILLER_123_641 VGND VGND VPWR VPWR sky130_fd_sc_hd__decap_3
XFILLER_69_706 VGND VGND VPWR VPWR sky130_fd_sc_hd__decap_3
XFILLER_110_302 VGND VGND VPWR VPWR sky130_fd_sc_hd__decap_3
XFILLER_122_195 VGND VGND VPWR VPWR sky130_fd_sc_hd__fill_1
XFILLER_96_569 VGND VGND VPWR VPWR sky130_fd_sc_hd__decap_3
XFILLER_49_452 VGND VGND VPWR VPWR sky130_fd_sc_hd__fill_1
XFILLER_110_368 VGND VGND VPWR VPWR sky130_fd_sc_hd__fill_2
XFILLER_37_603 VGND VGND VPWR VPWR sky130_fd_sc_hd__decap_3
XFILLER_83_219 VGND VGND VPWR VPWR sky130_fd_sc_hd__decap_3
XFILLER_76_271 VGND VGND VPWR VPWR sky130_fd_sc_hd__decap_3
XFILLER_92_731 VGND VGND VPWR VPWR sky130_fd_sc_hd__decap_3
XFILLER_76_282 VGND VGND VPWR VPWR sky130_fd_sc_hd__decap_3
XFILLER_37_647 VGND VGND VPWR VPWR sky130_fd_sc_hd__decap_3
XFILLER_64_444 VGND VGND VPWR VPWR sky130_fd_sc_hd__decap_3
XTAP_TAPCELL_ROW_65_1109 VGND VPWR sky130_fd_sc_hd__tapvpwrvgnd_1
XFILLER_91_252 VGND VGND VPWR VPWR sky130_fd_sc_hd__decap_3
XFILLER_64_477 VGND VGND VPWR VPWR sky130_fd_sc_hd__decap_3
XFILLER_52_628 VGND VGND VPWR VPWR sky130_fd_sc_hd__decap_3
X_4951_ _4949_/Y _4950_/Y _4918_/B VGND VGND VPWR VPWR _4951_/Y sky130_fd_sc_hd__a21oi_2
XFILLER_45_691 VGND VGND VPWR VPWR sky130_fd_sc_hd__decap_3
XFILLER_17_382 VGND VGND VPWR VPWR sky130_fd_sc_hd__decap_3
X_3902_ _6918_/Q _3926_/A2 _3925_/B1 _6870_/Q VGND VGND VPWR VPWR _3902_/X sky130_fd_sc_hd__a22o_2
X_4882_ _4882_/A _4882_/B VGND VGND VPWR VPWR _6998_/D sky130_fd_sc_hd__and2_2
XFILLER_60_672 VGND VGND VPWR VPWR sky130_fd_sc_hd__decap_3
XFILLER_32_363 VGND VGND VPWR VPWR sky130_fd_sc_hd__fill_1
X_6621_ _6621_/A VGND VGND VPWR VPWR _6621_/Y sky130_fd_sc_hd__inv_2
X_3833_ _7388_/Q _3832_/X _3860_/S VGND VGND VPWR VPWR _7388_/D sky130_fd_sc_hd__mux2_2
XFILLER_32_374 VGND VGND VPWR VPWR sky130_fd_sc_hd__fill_2
X_6552_ _6654_/A VGND VGND VPWR VPWR _6552_/Y sky130_fd_sc_hd__inv_2
XFILLER_20_569 VGND VGND VPWR VPWR sky130_fd_sc_hd__decap_3
X_3764_ _6706_/Q _6796_/Q _6884_/Q _6932_/Q _3991_/B _3665_/B VGND VGND VPWR VPWR
+ _3764_/X sky130_fd_sc_hd__mux4_2
XFILLER_9_570 VGND VGND VPWR VPWR sky130_fd_sc_hd__decap_3
XFILLER_118_424 VGND VGND VPWR VPWR sky130_fd_sc_hd__decap_3
X_6483_ _6650_/A VGND VGND VPWR VPWR _6483_/Y sky130_fd_sc_hd__inv_2
X_3695_ _6714_/Q _3767_/A2 _3759_/B1 _6892_/Q VGND VGND VPWR VPWR _3695_/X sky130_fd_sc_hd__a22o_2
XFILLER_106_619 VGND VGND VPWR VPWR sky130_fd_sc_hd__decap_3
XTAP_TAPCELL_ROW_76_1249 VGND VPWR sky130_fd_sc_hd__tapvpwrvgnd_1
X_5365_ _5365_/A0 _4716_/X _5383_/S VGND VGND VPWR VPWR _7150_/D sky130_fd_sc_hd__mux2_4
X_7104_ _7359_/CLK _7104_/D _6384_/Y VGND VGND VPWR VPWR _7104_/Q sky130_fd_sc_hd__dfrtp_2
XFILLER_114_663 VGND VGND VPWR VPWR sky130_fd_sc_hd__decap_3
X_4316_ _7226_/Q _4349_/B1 _4341_/B1 _7130_/Q VGND VGND VPWR VPWR _4316_/X sky130_fd_sc_hd__a22o_2
XFILLER_59_216 VGND VGND VPWR VPWR sky130_fd_sc_hd__decap_3
X_5296_ _5296_/A0 _4716_/X _5315_/S VGND VGND VPWR VPWR _7182_/D sky130_fd_sc_hd__mux2_4
XFILLER_114_696 VGND VGND VPWR VPWR sky130_fd_sc_hd__decap_3
XFILLER_113_184 VGND VGND VPWR VPWR sky130_fd_sc_hd__decap_3
X_7035_ _7387_/CLK _7035_/D _6315_/Y VGND VGND VPWR VPWR _7035_/Q sky130_fd_sc_hd__dfrtp_2
X_4247_ _7261_/Q _4356_/A2 _3966_/S _7325_/Q _4246_/X VGND VGND VPWR VPWR _4248_/C
+ sky130_fd_sc_hd__a221o_2
XFILLER_75_709 VGND VGND VPWR VPWR sky130_fd_sc_hd__decap_3
XFILLER_101_368 VGND VGND VPWR VPWR sky130_fd_sc_hd__decap_3
X_4178_ _7264_/Q _4356_/A2 _4177_/X VGND VGND VPWR VPWR _4178_/Y sky130_fd_sc_hd__a21oi_2
XFILLER_67_260 VGND VGND VPWR VPWR sky130_fd_sc_hd__decap_3
XFILLER_28_625 VGND VGND VPWR VPWR sky130_fd_sc_hd__decap_3
XFILLER_55_411 VGND VGND VPWR VPWR sky130_fd_sc_hd__decap_3
XFILLER_95_591 VGND VGND VPWR VPWR sky130_fd_sc_hd__decap_3
XFILLER_27_113 VGND VGND VPWR VPWR sky130_fd_sc_hd__decap_3
XFILLER_28_669 VGND VGND VPWR VPWR sky130_fd_sc_hd__decap_3
XFILLER_27_157 VGND VGND VPWR VPWR sky130_fd_sc_hd__fill_2
XTAP_TAPCELL_ROW_2_289 VGND VPWR sky130_fd_sc_hd__tapvpwrvgnd_1
XFILLER_43_617 VGND VGND VPWR VPWR sky130_fd_sc_hd__decap_3
XFILLER_82_274 VGND VGND VPWR VPWR sky130_fd_sc_hd__decap_3
XFILLER_82_296 VGND VGND VPWR VPWR sky130_fd_sc_hd__decap_3
XFILLER_35_69 VGND VGND VPWR VPWR sky130_fd_sc_hd__decap_3
XFILLER_51_650 VGND VGND VPWR VPWR sky130_fd_sc_hd__decap_3
XFILLER_11_503 VGND VGND VPWR VPWR sky130_fd_sc_hd__fill_1
X_6819_ clkload9/A _6819_/D VGND VGND VPWR VPWR _6819_/Q sky130_fd_sc_hd__dfxtp_2
XFILLER_51_694 VGND VGND VPWR VPWR sky130_fd_sc_hd__decap_3
XFILLER_23_396 VGND VGND VPWR VPWR sky130_fd_sc_hd__decap_3
XFILLER_11_547 VGND VGND VPWR VPWR sky130_fd_sc_hd__decap_3
XFILLER_50_193 VGND VGND VPWR VPWR sky130_fd_sc_hd__decap_3
XTAP_TAPCELL_ROW_21_542 VGND VPWR sky130_fd_sc_hd__tapvpwrvgnd_1
XFILLER_51_57 VGND VGND VPWR VPWR sky130_fd_sc_hd__decap_3
XFILLER_109_402 VGND VGND VPWR VPWR sky130_fd_sc_hd__decap_3
XFILLER_3_724 VGND VGND VPWR VPWR sky130_fd_sc_hd__decap_3
XFILLER_2_212 VGND VGND VPWR VPWR sky130_fd_sc_hd__decap_3
XFILLER_105_641 VGND VGND VPWR VPWR sky130_fd_sc_hd__decap_3
XFILLER_105_685 VGND VGND VPWR VPWR sky130_fd_sc_hd__decap_3
XFILLER_78_525 VGND VGND VPWR VPWR sky130_fd_sc_hd__decap_3
XFILLER_116_50 VGND VGND VPWR VPWR sky130_fd_sc_hd__decap_3
XFILLER_120_622 VGND VGND VPWR VPWR sky130_fd_sc_hd__decap_3
XFILLER_104_184 VGND VGND VPWR VPWR sky130_fd_sc_hd__decap_3
XFILLER_78_569 VGND VGND VPWR VPWR sky130_fd_sc_hd__decap_3
XFILLER_116_83 VGND VGND VPWR VPWR sky130_fd_sc_hd__fill_1
XTAP_TAPCELL_ROW_49_907 VGND VPWR sky130_fd_sc_hd__tapvpwrvgnd_1
XFILLER_120_666 VGND VGND VPWR VPWR sky130_fd_sc_hd__decap_3
XFILLER_116_94 VGND VGND VPWR VPWR sky130_fd_sc_hd__decap_3
XFILLER_76_54 VGND VGND VPWR VPWR sky130_fd_sc_hd__decap_3
XFILLER_19_603 VGND VGND VPWR VPWR sky130_fd_sc_hd__decap_3
XFILLER_76_65 VGND VGND VPWR VPWR sky130_fd_sc_hd__decap_3
XFILLER_65_219 VGND VGND VPWR VPWR sky130_fd_sc_hd__decap_3
XFILLER_58_260 VGND VGND VPWR VPWR sky130_fd_sc_hd__decap_3
XFILLER_120_699 VGND VGND VPWR VPWR sky130_fd_sc_hd__fill_1
XFILLER_86_580 VGND VGND VPWR VPWR sky130_fd_sc_hd__decap_3
XFILLER_74_731 VGND VGND VPWR VPWR sky130_fd_sc_hd__decap_3
XFILLER_58_282 VGND VGND VPWR VPWR sky130_fd_sc_hd__fill_1
XFILLER_19_647 VGND VGND VPWR VPWR sky130_fd_sc_hd__decap_3
XTAP_TAPCELL_ROW_29_642 VGND VPWR sky130_fd_sc_hd__tapvpwrvgnd_1
XFILLER_73_252 VGND VGND VPWR VPWR sky130_fd_sc_hd__decap_3
XFILLER_46_477 VGND VGND VPWR VPWR sky130_fd_sc_hd__decap_3
XFILLER_61_403 VGND VGND VPWR VPWR sky130_fd_sc_hd__decap_3
XFILLER_34_628 VGND VGND VPWR VPWR sky130_fd_sc_hd__decap_3
XFILLER_73_296 VGND VGND VPWR VPWR sky130_fd_sc_hd__decap_3
XFILLER_61_436 VGND VGND VPWR VPWR sky130_fd_sc_hd__decap_3
XFILLER_27_691 VGND VGND VPWR VPWR sky130_fd_sc_hd__decap_3
XPHY_EDGE_ROW_1_Left_125 VGND VGND VPWR VPWR sky130_fd_sc_hd__decap_3
XFILLER_61_458 VGND VGND VPWR VPWR sky130_fd_sc_hd__decap_3
XFILLER_92_97 VGND VGND VPWR VPWR sky130_fd_sc_hd__fill_2
XFILLER_14_352 VGND VGND VPWR VPWR sky130_fd_sc_hd__fill_1
XFILLER_42_672 VGND VGND VPWR VPWR sky130_fd_sc_hd__decap_3
XFILLER_14_363 VGND VGND VPWR VPWR sky130_fd_sc_hd__fill_1
XFILLER_14_374 VGND VGND VPWR VPWR sky130_fd_sc_hd__decap_3
XFILLER_6_551 VGND VGND VPWR VPWR sky130_fd_sc_hd__decap_3
X_3480_ _7088_/Q _4335_/B1 _3407_/X _7120_/Q VGND VGND VPWR VPWR _3482_/B sky130_fd_sc_hd__a22o_2
XFILLER_115_427 VGND VGND VPWR VPWR sky130_fd_sc_hd__decap_3
XFILLER_6_584 VGND VGND VPWR VPWR sky130_fd_sc_hd__decap_3
XFILLER_6_595 VGND VGND VPWR VPWR sky130_fd_sc_hd__decap_3
XFILLER_115_449 VGND VGND VPWR VPWR sky130_fd_sc_hd__decap_3
X_5150_ _3501_/X _3618_/X _5145_/X _5149_/Y VGND VGND VPWR VPWR _5659_/B sky130_fd_sc_hd__a31o_2
XFILLER_111_600 VGND VGND VPWR VPWR sky130_fd_sc_hd__decap_3
XFILLER_37_3 VGND VGND VPWR VPWR sky130_fd_sc_hd__decap_3
X_4101_ _7141_/Q _4348_/B1 _4100_/X VGND VGND VPWR VPWR _4141_/A sky130_fd_sc_hd__a21oi_2
XFILLER_111_644 VGND VGND VPWR VPWR sky130_fd_sc_hd__decap_3
XFILLER_96_344 VGND VGND VPWR VPWR sky130_fd_sc_hd__decap_3
XFILLER_57_709 VGND VGND VPWR VPWR sky130_fd_sc_hd__decap_3
X_4032_ _7246_/Q _4433_/B _3943_/S _7214_/Q VGND VGND VPWR VPWR _4032_/X sky130_fd_sc_hd__a22o_2
XFILLER_111_688 VGND VGND VPWR VPWR sky130_fd_sc_hd__decap_3
XFILLER_84_528 VGND VGND VPWR VPWR sky130_fd_sc_hd__decap_3
XFILLER_110_165 VGND VGND VPWR VPWR sky130_fd_sc_hd__fill_2
XFILLER_110_187 VGND VGND VPWR VPWR sky130_fd_sc_hd__decap_3
XFILLER_37_422 VGND VGND VPWR VPWR sky130_fd_sc_hd__decap_3
XFILLER_49_293 VGND VGND VPWR VPWR sky130_fd_sc_hd__decap_3
XFILLER_37_444 VGND VGND VPWR VPWR sky130_fd_sc_hd__decap_3
XFILLER_37_455 VGND VGND VPWR VPWR sky130_fd_sc_hd__fill_1
XFILLER_92_550 VGND VGND VPWR VPWR sky130_fd_sc_hd__decap_3
XFILLER_25_606 VGND VGND VPWR VPWR sky130_fd_sc_hd__decap_3
XFILLER_80_701 VGND VGND VPWR VPWR sky130_fd_sc_hd__decap_3
XFILLER_25_617 VGND VGND VPWR VPWR sky130_fd_sc_hd__decap_3
XFILLER_92_583 VGND VGND VPWR VPWR sky130_fd_sc_hd__decap_3
XFILLER_64_274 VGND VGND VPWR VPWR sky130_fd_sc_hd__decap_3
XFILLER_52_414 VGND VGND VPWR VPWR sky130_fd_sc_hd__fill_1
XFILLER_37_488 VGND VGND VPWR VPWR sky130_fd_sc_hd__decap_3
XFILLER_24_105 VGND VGND VPWR VPWR sky130_fd_sc_hd__fill_2
XFILLER_80_734 VGND VGND VPWR VPWR sky130_fd_sc_hd__fill_1
XFILLER_24_127 VGND VGND VPWR VPWR sky130_fd_sc_hd__decap_3
XFILLER_52_458 VGND VGND VPWR VPWR sky130_fd_sc_hd__decap_3
XFILLER_33_650 VGND VGND VPWR VPWR sky130_fd_sc_hd__decap_3
X_4865_ _4865_/A0 _4864_/X _4914_/S VGND VGND VPWR VPWR _7270_/D sky130_fd_sc_hd__mux2_2
XFILLER_60_480 VGND VGND VPWR VPWR sky130_fd_sc_hd__decap_3
XFILLER_33_694 VGND VGND VPWR VPWR sky130_fd_sc_hd__decap_3
XANTENNA_12 _7361_/Q VGND VGND VPWR VPWR sky130_fd_sc_hd__diode_2
X_6604_ _6638_/A VGND VGND VPWR VPWR _6604_/Y sky130_fd_sc_hd__inv_2
XFILLER_119_700 VGND VGND VPWR VPWR sky130_fd_sc_hd__decap_3
X_3816_ _6792_/Q _3926_/B1 _3925_/B1 _6880_/Q _3815_/X VGND VGND VPWR VPWR _3816_/X
+ sky130_fd_sc_hd__a221o_2
X_4796_ _4647_/C _4779_/X _4447_/B _4780_/Y _4814_/A VGND VGND VPWR VPWR _4796_/Y
+ sky130_fd_sc_hd__a311oi_2
X_6535_ _6624_/A VGND VGND VPWR VPWR _6535_/Y sky130_fd_sc_hd__inv_2
XFILLER_118_221 VGND VGND VPWR VPWR sky130_fd_sc_hd__decap_3
X_3747_ _3741_/X _3743_/X _3745_/X _3746_/X VGND VGND VPWR VPWR _3747_/X sky130_fd_sc_hd__a22o_2
XFILLER_118_265 VGND VGND VPWR VPWR sky130_fd_sc_hd__fill_2
X_6466_ _6602_/A VGND VGND VPWR VPWR _6466_/Y sky130_fd_sc_hd__inv_2
XPHY_EDGE_ROW_65_Left_189 VGND VGND VPWR VPWR sky130_fd_sc_hd__decap_3
X_5417_ _5417_/A0 _5125_/Y _5429_/S VGND VGND VPWR VPWR _7125_/D sky130_fd_sc_hd__mux2_2
X_6397_ _6462_/A VGND VGND VPWR VPWR _6397_/Y sky130_fd_sc_hd__inv_2
XFILLER_0_716 VGND VGND VPWR VPWR sky130_fd_sc_hd__fill_1
X_5348_ _7157_/Q _5125_/Y _7412_/A VGND VGND VPWR VPWR _7157_/D sky130_fd_sc_hd__mux2_2
XFILLER_99_160 VGND VGND VPWR VPWR sky130_fd_sc_hd__decap_3
XFILLER_102_622 VGND VGND VPWR VPWR sky130_fd_sc_hd__decap_3
XTAP_TAPCELL_ROW_7_359 VGND VPWR sky130_fd_sc_hd__tapvpwrvgnd_1
XFILLER_99_193 VGND VGND VPWR VPWR sky130_fd_sc_hd__decap_3
XFILLER_101_110 VGND VGND VPWR VPWR sky130_fd_sc_hd__fill_2
XFILLER_102_666 VGND VGND VPWR VPWR sky130_fd_sc_hd__decap_3
XTAP_TAPCELL_ROW_89_1418 VGND VPWR sky130_fd_sc_hd__tapvpwrvgnd_1
XTAP_TAPCELL_ROW_89_1429 VGND VPWR sky130_fd_sc_hd__tapvpwrvgnd_1
X_7018_ _7365_/CLK _7018_/D _6298_/Y VGND VGND VPWR VPWR _7018_/Q sky130_fd_sc_hd__dfrtp_2
XFILLER_87_399 VGND VGND VPWR VPWR sky130_fd_sc_hd__decap_3
XFILLER_75_539 VGND VGND VPWR VPWR sky130_fd_sc_hd__decap_3
XFILLER_102_699 VGND VGND VPWR VPWR sky130_fd_sc_hd__fill_1
XFILLER_56_731 VGND VGND VPWR VPWR sky130_fd_sc_hd__decap_3
XFILLER_90_509 VGND VGND VPWR VPWR sky130_fd_sc_hd__fill_2
XPHY_EDGE_ROW_74_Left_198 VGND VGND VPWR VPWR sky130_fd_sc_hd__decap_3
XFILLER_71_712 VGND VGND VPWR VPWR sky130_fd_sc_hd__decap_3
XFILLER_28_477 VGND VGND VPWR VPWR sky130_fd_sc_hd__decap_3
XTAP_TAPCELL_ROW_26_601 VGND VPWR sky130_fd_sc_hd__tapvpwrvgnd_1
XFILLER_43_414 VGND VGND VPWR VPWR sky130_fd_sc_hd__decap_3
XFILLER_16_628 VGND VGND VPWR VPWR sky130_fd_sc_hd__decap_3
XFILLER_83_594 VGND VGND VPWR VPWR sky130_fd_sc_hd__decap_3
XFILLER_15_116 VGND VGND VPWR VPWR sky130_fd_sc_hd__fill_1
XFILLER_70_233 VGND VGND VPWR VPWR sky130_fd_sc_hd__decap_3
XFILLER_43_458 VGND VGND VPWR VPWR sky130_fd_sc_hd__decap_3
XTAP_TAPCELL_ROW_54_965 VGND VPWR sky130_fd_sc_hd__tapvpwrvgnd_1
XFILLER_31_609 VGND VGND VPWR VPWR sky130_fd_sc_hd__decap_3
XFILLER_62_23 VGND VGND VPWR VPWR sky130_fd_sc_hd__decap_3
XFILLER_70_266 VGND VGND VPWR VPWR sky130_fd_sc_hd__decap_3
XFILLER_24_672 VGND VGND VPWR VPWR sky130_fd_sc_hd__decap_3
XFILLER_70_299 VGND VGND VPWR VPWR sky130_fd_sc_hd__decap_3
XFILLER_11_322 VGND VGND VPWR VPWR sky130_fd_sc_hd__decap_3
XFILLER_7_326 VGND VGND VPWR VPWR sky130_fd_sc_hd__decap_3
XFILLER_109_210 VGND VGND VPWR VPWR sky130_fd_sc_hd__decap_3
XFILLER_7_337 VGND VGND VPWR VPWR sky130_fd_sc_hd__decap_3
XFILLER_11_399 VGND VGND VPWR VPWR sky130_fd_sc_hd__decap_3
XFILLER_109_287 VGND VGND VPWR VPWR sky130_fd_sc_hd__decap_3
XFILLER_109_298 VGND VGND VPWR VPWR sky130_fd_sc_hd__decap_3
XFILLER_3_532 VGND VGND VPWR VPWR sky130_fd_sc_hd__decap_3
XFILLER_11_82 VGND VGND VPWR VPWR sky130_fd_sc_hd__decap_3
XFILLER_112_408 VGND VGND VPWR VPWR sky130_fd_sc_hd__decap_3
XTAP_TAPCELL_ROW_111_1714 VGND VPWR sky130_fd_sc_hd__tapvpwrvgnd_1
XFILLER_3_576 VGND VGND VPWR VPWR sky130_fd_sc_hd__decap_3
XFILLER_105_460 VGND VGND VPWR VPWR sky130_fd_sc_hd__decap_3
XFILLER_105_493 VGND VGND VPWR VPWR sky130_fd_sc_hd__fill_2
XFILLER_39_709 VGND VGND VPWR VPWR sky130_fd_sc_hd__decap_3
XFILLER_93_303 VGND VGND VPWR VPWR sky130_fd_sc_hd__decap_3
XFILLER_78_377 VGND VGND VPWR VPWR sky130_fd_sc_hd__decap_3
XFILLER_120_463 VGND VGND VPWR VPWR sky130_fd_sc_hd__decap_3
XFILLER_66_539 VGND VGND VPWR VPWR sky130_fd_sc_hd__fill_1
XFILLER_78_399 VGND VGND VPWR VPWR sky130_fd_sc_hd__decap_3
XFILLER_19_411 VGND VGND VPWR VPWR sky130_fd_sc_hd__decap_3
XFILLER_62_701 VGND VGND VPWR VPWR sky130_fd_sc_hd__decap_3
XFILLER_19_466 VGND VGND VPWR VPWR sky130_fd_sc_hd__decap_3
XTAP_TAPCELL_ROW_109_1687 VGND VPWR sky130_fd_sc_hd__tapvpwrvgnd_1
XFILLER_61_200 VGND VGND VPWR VPWR sky130_fd_sc_hd__decap_3
XFILLER_46_274 VGND VGND VPWR VPWR sky130_fd_sc_hd__decap_3
XFILLER_19_488 VGND VGND VPWR VPWR sky130_fd_sc_hd__fill_2
XFILLER_62_734 VGND VGND VPWR VPWR sky130_fd_sc_hd__fill_1
XFILLER_34_436 VGND VGND VPWR VPWR sky130_fd_sc_hd__decap_3
XFILLER_34_469 VGND VGND VPWR VPWR sky130_fd_sc_hd__decap_3
XFILLER_15_650 VGND VGND VPWR VPWR sky130_fd_sc_hd__decap_3
XTAP_TAPCELL_ROW_122_1854 VGND VPWR sky130_fd_sc_hd__tapvpwrvgnd_1
XFILLER_15_694 VGND VGND VPWR VPWR sky130_fd_sc_hd__decap_3
XFILLER_42_480 VGND VGND VPWR VPWR sky130_fd_sc_hd__decap_3
XFILLER_30_631 VGND VGND VPWR VPWR sky130_fd_sc_hd__decap_3
X_4650_ _4440_/A _4650_/B VGND VGND VPWR VPWR _4810_/B sky130_fd_sc_hd__and2b_2
XFILLER_30_675 VGND VGND VPWR VPWR sky130_fd_sc_hd__decap_3
X_3601_ _3427_/B _3600_/Y _3599_/A VGND VGND VPWR VPWR _4613_/B sky130_fd_sc_hd__a21oi_2
X_4581_ _4581_/A _4595_/B VGND VGND VPWR VPWR _7290_/D sky130_fd_sc_hd__and2_2
X_6320_ _6544_/A VGND VGND VPWR VPWR _6320_/Y sky130_fd_sc_hd__inv_2
X_3532_ _5135_/A1 _3509_/Y _5642_/B _5659_/A _4471_/S VGND VGND VPWR VPWR _3621_/A
+ sky130_fd_sc_hd__a41o_2
Xhold805 _6850_/Q VGND VGND VPWR VPWR _6850_/D sky130_fd_sc_hd__dlygate4sd3_1
XFILLER_116_725 VGND VGND VPWR VPWR sky130_fd_sc_hd__decap_3
Xhold816 _6898_/Q VGND VGND VPWR VPWR _6898_/D sky130_fd_sc_hd__dlygate4sd3_1
Xhold827 _6805_/Q VGND VGND VPWR VPWR _6805_/D sky130_fd_sc_hd__dlygate4sd3_1
Xhold838 _6894_/Q VGND VGND VPWR VPWR _6894_/D sky130_fd_sc_hd__dlygate4sd3_1
Xmax_cap557 _4273_/Y VGND VGND VPWR VPWR _4994_/A2 sky130_fd_sc_hd__clkdlybuf4s25_1
Xhold849 _7118_/Q VGND VGND VPWR VPWR _7118_/D sky130_fd_sc_hd__dlygate4sd3_1
XFILLER_89_609 VGND VGND VPWR VPWR sky130_fd_sc_hd__decap_3
XTAP_TAPCELL_ROW_73_1219 VGND VPWR sky130_fd_sc_hd__tapvpwrvgnd_1
X_3463_ _7057_/Q _4305_/B _3429_/X _3462_/X VGND VGND VPWR VPWR _3545_/A sky130_fd_sc_hd__o211ai_4
XFILLER_107_19 VGND VGND VPWR VPWR sky130_fd_sc_hd__decap_3
XFILLER_115_257 VGND VGND VPWR VPWR sky130_fd_sc_hd__decap_3
XFILLER_97_620 VGND VGND VPWR VPWR sky130_fd_sc_hd__decap_3
X_3394_ _3394_/A _3429_/B VGND VGND VPWR VPWR _3558_/B sky130_fd_sc_hd__or2_2
XFILLER_69_333 VGND VGND VPWR VPWR sky130_fd_sc_hd__decap_3
XFILLER_97_653 VGND VGND VPWR VPWR sky130_fd_sc_hd__decap_3
XFILLER_111_430 VGND VGND VPWR VPWR sky130_fd_sc_hd__decap_3
XTAP_TAPCELL_ROW_4_318 VGND VPWR sky130_fd_sc_hd__tapvpwrvgnd_1
XFILLER_96_141 VGND VGND VPWR VPWR sky130_fd_sc_hd__decap_3
XFILLER_69_366 VGND VGND VPWR VPWR sky130_fd_sc_hd__decap_3
XFILLER_84_303 VGND VGND VPWR VPWR sky130_fd_sc_hd__decap_3
XFILLER_97_697 VGND VGND VPWR VPWR sky130_fd_sc_hd__decap_3
XFILLER_57_528 VGND VGND VPWR VPWR sky130_fd_sc_hd__decap_3
XFILLER_69_399 VGND VGND VPWR VPWR sky130_fd_sc_hd__decap_3
XFILLER_123_29 VGND VGND VPWR VPWR sky130_fd_sc_hd__decap_3
XFILLER_38_731 VGND VGND VPWR VPWR sky130_fd_sc_hd__decap_3
XFILLER_84_347 VGND VGND VPWR VPWR sky130_fd_sc_hd__fill_1
XFILLER_65_561 VGND VGND VPWR VPWR sky130_fd_sc_hd__fill_1
XFILLER_37_252 VGND VGND VPWR VPWR sky130_fd_sc_hd__decap_3
XFILLER_53_712 VGND VGND VPWR VPWR sky130_fd_sc_hd__decap_3
XFILLER_65_583 VGND VGND VPWR VPWR sky130_fd_sc_hd__decap_3
XFILLER_37_274 VGND VGND VPWR VPWR sky130_fd_sc_hd__decap_3
XFILLER_25_436 VGND VGND VPWR VPWR sky130_fd_sc_hd__decap_3
XFILLER_80_531 VGND VGND VPWR VPWR sky130_fd_sc_hd__fill_1
XFILLER_37_296 VGND VGND VPWR VPWR sky130_fd_sc_hd__decap_3
XTAP_TAPCELL_ROW_84_1359 VGND VPWR sky130_fd_sc_hd__tapvpwrvgnd_1
XFILLER_13_609 VGND VGND VPWR VPWR sky130_fd_sc_hd__decap_3
XFILLER_52_266 VGND VGND VPWR VPWR sky130_fd_sc_hd__decap_3
XFILLER_40_406 VGND VGND VPWR VPWR sky130_fd_sc_hd__decap_3
XTAP_TAPCELL_ROW_51_924 VGND VPWR sky130_fd_sc_hd__tapvpwrvgnd_1
XTAP_TAPCELL_ROW_51_935 VGND VPWR sky130_fd_sc_hd__tapvpwrvgnd_1
X_4917_ _4967_/A _4950_/A _4967_/B VGND VGND VPWR VPWR _4918_/B sky130_fd_sc_hd__and3_2
XFILLER_21_620 VGND VGND VPWR VPWR sky130_fd_sc_hd__decap_3
XFILLER_21_653 VGND VGND VPWR VPWR sky130_fd_sc_hd__decap_3
X_4848_ _4884_/A _4904_/B _4140_/X VGND VGND VPWR VPWR _4872_/B sky130_fd_sc_hd__o21ba_2
XFILLER_20_141 VGND VGND VPWR VPWR sky130_fd_sc_hd__decap_3
XTAP_TAPCELL_ROW_31_670 VGND VPWR sky130_fd_sc_hd__tapvpwrvgnd_1
XFILLER_21_697 VGND VGND VPWR VPWR sky130_fd_sc_hd__decap_3
XFILLER_119_541 VGND VGND VPWR VPWR sky130_fd_sc_hd__decap_3
X_4779_ _4779_/A _4827_/B VGND VGND VPWR VPWR _4779_/X sky130_fd_sc_hd__or2_2
XFILLER_107_703 VGND VGND VPWR VPWR sky130_fd_sc_hd__decap_3
XFILLER_4_307 VGND VGND VPWR VPWR sky130_fd_sc_hd__fill_1
X_6518_ _6520_/A VGND VGND VPWR VPWR _6518_/Y sky130_fd_sc_hd__inv_2
XFILLER_4_318 VGND VGND VPWR VPWR sky130_fd_sc_hd__decap_3
XFILLER_119_585 VGND VGND VPWR VPWR sky130_fd_sc_hd__decap_3
XFILLER_106_6 VGND VGND VPWR VPWR sky130_fd_sc_hd__decap_3
X_6449_ _6643_/A VGND VGND VPWR VPWR _6449_/Y sky130_fd_sc_hd__inv_2
XFILLER_106_246 VGND VGND VPWR VPWR sky130_fd_sc_hd__decap_3
XTAP_TAPCELL_ROW_95_1499 VGND VPWR sky130_fd_sc_hd__tapvpwrvgnd_1
XFILLER_106_268 VGND VGND VPWR VPWR sky130_fd_sc_hd__decap_3
XFILLER_79_119 VGND VGND VPWR VPWR sky130_fd_sc_hd__decap_3
XFILLER_0_513 VGND VGND VPWR VPWR sky130_fd_sc_hd__decap_3
XFILLER_88_631 VGND VGND VPWR VPWR sky130_fd_sc_hd__decap_3
XFILLER_121_238 VGND VGND VPWR VPWR sky130_fd_sc_hd__decap_3
XFILLER_102_430 VGND VGND VPWR VPWR sky130_fd_sc_hd__fill_1
XFILLER_0_557 VGND VGND VPWR VPWR sky130_fd_sc_hd__decap_3
XFILLER_102_452 VGND VGND VPWR VPWR sky130_fd_sc_hd__decap_3
XFILLER_88_675 VGND VGND VPWR VPWR sky130_fd_sc_hd__decap_3
XFILLER_87_152 VGND VGND VPWR VPWR sky130_fd_sc_hd__decap_3
XFILLER_57_45 VGND VGND VPWR VPWR sky130_fd_sc_hd__fill_2
XPHY_EDGE_ROW_82_Left_206 VGND VGND VPWR VPWR sky130_fd_sc_hd__decap_3
XFILLER_57_78 VGND VGND VPWR VPWR sky130_fd_sc_hd__decap_3
XFILLER_75_369 VGND VGND VPWR VPWR sky130_fd_sc_hd__decap_3
XFILLER_28_230 VGND VGND VPWR VPWR sky130_fd_sc_hd__decap_3
XFILLER_44_701 VGND VGND VPWR VPWR sky130_fd_sc_hd__decap_3
XFILLER_113_51 VGND VGND VPWR VPWR sky130_fd_sc_hd__decap_3
XTAP_TAPCELL_ROW_39_770 VGND VPWR sky130_fd_sc_hd__tapvpwrvgnd_1
XFILLER_90_339 VGND VGND VPWR VPWR sky130_fd_sc_hd__decap_3
XFILLER_28_274 VGND VGND VPWR VPWR sky130_fd_sc_hd__decap_3
XFILLER_44_734 VGND VGND VPWR VPWR sky130_fd_sc_hd__fill_1
XFILLER_113_84 VGND VGND VPWR VPWR sky130_fd_sc_hd__decap_3
XFILLER_71_531 VGND VGND VPWR VPWR sky130_fd_sc_hd__decap_3
XFILLER_43_222 VGND VGND VPWR VPWR sky130_fd_sc_hd__fill_2
XFILLER_71_542 VGND VGND VPWR VPWR sky130_fd_sc_hd__decap_3
XFILLER_71_564 VGND VGND VPWR VPWR sky130_fd_sc_hd__decap_3
XFILLER_43_255 VGND VGND VPWR VPWR sky130_fd_sc_hd__decap_3
XFILLER_43_266 VGND VGND VPWR VPWR sky130_fd_sc_hd__decap_3
XFILLER_12_631 VGND VGND VPWR VPWR sky130_fd_sc_hd__decap_3
XFILLER_8_613 VGND VGND VPWR VPWR sky130_fd_sc_hd__decap_3
XFILLER_12_675 VGND VGND VPWR VPWR sky130_fd_sc_hd__decap_3
XPHY_EDGE_ROW_91_Left_215 VGND VGND VPWR VPWR sky130_fd_sc_hd__decap_3
XFILLER_8_657 VGND VGND VPWR VPWR sky130_fd_sc_hd__decap_3
XFILLER_7_178 VGND VGND VPWR VPWR sky130_fd_sc_hd__decap_3
XTAP_TAPCELL_ROW_59_1030 VGND VPWR sky130_fd_sc_hd__tapvpwrvgnd_1
XFILLER_113_706 VGND VGND VPWR VPWR sky130_fd_sc_hd__decap_3
XFILLER_98_417 VGND VGND VPWR VPWR sky130_fd_sc_hd__decap_3
XFILLER_3_351 VGND VGND VPWR VPWR sky130_fd_sc_hd__fill_2
XFILLER_98_439 VGND VGND VPWR VPWR sky130_fd_sc_hd__decap_3
XFILLER_79_620 VGND VGND VPWR VPWR sky130_fd_sc_hd__decap_3
XFILLER_3_373 VGND VGND VPWR VPWR sky130_fd_sc_hd__decap_3
XFILLER_112_227 VGND VGND VPWR VPWR sky130_fd_sc_hd__decap_3
XFILLER_79_653 VGND VGND VPWR VPWR sky130_fd_sc_hd__decap_3
XFILLER_78_130 VGND VGND VPWR VPWR sky130_fd_sc_hd__decap_3
XFILLER_78_141 VGND VGND VPWR VPWR sky130_fd_sc_hd__decap_3
XFILLER_94_601 VGND VGND VPWR VPWR sky130_fd_sc_hd__decap_3
XFILLER_79_697 VGND VGND VPWR VPWR sky130_fd_sc_hd__decap_3
XFILLER_78_174 VGND VGND VPWR VPWR sky130_fd_sc_hd__decap_3
XFILLER_94_634 VGND VGND VPWR VPWR sky130_fd_sc_hd__decap_3
XFILLER_120_271 VGND VGND VPWR VPWR sky130_fd_sc_hd__fill_2
XFILLER_94_645 VGND VGND VPWR VPWR sky130_fd_sc_hd__decap_3
XFILLER_120_282 VGND VGND VPWR VPWR sky130_fd_sc_hd__decap_3
XFILLER_94_678 VGND VGND VPWR VPWR sky130_fd_sc_hd__decap_3
XFILLER_47_550 VGND VGND VPWR VPWR sky130_fd_sc_hd__fill_2
XFILLER_47_561 VGND VGND VPWR VPWR sky130_fd_sc_hd__decap_3
XFILLER_19_252 VGND VGND VPWR VPWR sky130_fd_sc_hd__fill_1
XFILLER_35_712 VGND VGND VPWR VPWR sky130_fd_sc_hd__decap_3
XFILLER_62_520 VGND VGND VPWR VPWR sky130_fd_sc_hd__decap_3
XFILLER_74_380 VGND VGND VPWR VPWR sky130_fd_sc_hd__decap_3
XFILLER_34_222 VGND VGND VPWR VPWR sky130_fd_sc_hd__decap_3
XFILLER_50_704 VGND VGND VPWR VPWR sky130_fd_sc_hd__decap_3
XFILLER_22_417 VGND VGND VPWR VPWR sky130_fd_sc_hd__decap_3
XFILLER_34_277 VGND VGND VPWR VPWR sky130_fd_sc_hd__decap_3
XFILLER_34_288 VGND VGND VPWR VPWR sky130_fd_sc_hd__decap_3
XTAP_TAPCELL_ROW_17_486 VGND VPWR sky130_fd_sc_hd__tapvpwrvgnd_1
X_4702_ _6991_/Q _5026_/A VGND VGND VPWR VPWR _5001_/A sky130_fd_sc_hd__and2_2
X_5682_ _7347_/Q hold943/X _5708_/S VGND VGND VPWR VPWR _6691_/D sky130_fd_sc_hd__mux2_2
X_4633_ _4633_/A _4903_/A _4845_/A _4890_/B VGND VGND VPWR VPWR _4633_/X sky130_fd_sc_hd__or4_2
XFILLER_8_94 VGND VGND VPWR VPWR sky130_fd_sc_hd__decap_3
XFILLER_116_500 VGND VGND VPWR VPWR sky130_fd_sc_hd__decap_3
X_7352_ _7352_/CLK _7352_/D _6632_/Y VGND VGND VPWR VPWR _7352_/Q sky130_fd_sc_hd__dfrtp_2
XFILLER_118_18 VGND VGND VPWR VPWR sky130_fd_sc_hd__decap_3
Xhold602 _6907_/Q VGND VGND VPWR VPWR _6907_/D sky130_fd_sc_hd__dlygate4sd3_1
XFILLER_118_29 VGND VGND VPWR VPWR sky130_fd_sc_hd__decap_3
Xhold613 _6726_/Q VGND VGND VPWR VPWR _6726_/D sky130_fd_sc_hd__dlygate4sd3_1
XFILLER_116_533 VGND VGND VPWR VPWR sky130_fd_sc_hd__decap_3
X_6303_ _6618_/A VGND VGND VPWR VPWR _6303_/Y sky130_fd_sc_hd__inv_2
Xhold624 _6847_/Q VGND VGND VPWR VPWR _6847_/D sky130_fd_sc_hd__dlygate4sd3_1
X_3515_ _3509_/Y _3510_/X _4354_/B1 VGND VGND VPWR VPWR _4938_/A sky130_fd_sc_hd__a21o_2
Xhold635 _6800_/Q VGND VGND VPWR VPWR _6800_/D sky130_fd_sc_hd__dlygate4sd3_1
X_7283_ _7313_/CLK _7283_/D _6563_/Y VGND VGND VPWR VPWR _7283_/Q sky130_fd_sc_hd__dfrtp_2
X_4495_ _4495_/A0 _7300_/Q _4505_/S VGND VGND VPWR VPWR _7332_/D sky130_fd_sc_hd__mux2_2
Xhold646 _6914_/Q VGND VGND VPWR VPWR _6914_/D sky130_fd_sc_hd__dlygate4sd3_1
XFILLER_116_566 VGND VGND VPWR VPWR sky130_fd_sc_hd__decap_3
Xhold657 _6905_/Q VGND VGND VPWR VPWR _6905_/D sky130_fd_sc_hd__dlygate4sd3_1
Xhold668 _6833_/Q VGND VGND VPWR VPWR _6833_/D sky130_fd_sc_hd__dlygate4sd3_1
XFILLER_104_728 VGND VGND VPWR VPWR sky130_fd_sc_hd__decap_3
Xhold679 _6817_/Q VGND VGND VPWR VPWR _6817_/D sky130_fd_sc_hd__dlygate4sd3_1
XFILLER_89_439 VGND VGND VPWR VPWR sky130_fd_sc_hd__decap_3
X_3377_ _3394_/A _3429_/A _5641_/A _5161_/A VGND VGND VPWR VPWR _3377_/X sky130_fd_sc_hd__and4bb_4
XFILLER_69_152 VGND VGND VPWR VPWR sky130_fd_sc_hd__decap_3
XFILLER_85_612 VGND VGND VPWR VPWR sky130_fd_sc_hd__decap_3
XFILLER_57_303 VGND VGND VPWR VPWR sky130_fd_sc_hd__decap_3
X_5116_ _5110_/Y _5111_/X _5115_/X VGND VGND VPWR VPWR _5116_/Y sky130_fd_sc_hd__o21ai_2
XFILLER_97_483 VGND VGND VPWR VPWR sky130_fd_sc_hd__decap_3
XFILLER_85_623 VGND VGND VPWR VPWR sky130_fd_sc_hd__decap_3
XFILLER_97_494 VGND VGND VPWR VPWR sky130_fd_sc_hd__fill_1
XFILLER_111_271 VGND VGND VPWR VPWR sky130_fd_sc_hd__decap_3
XFILLER_84_122 VGND VGND VPWR VPWR sky130_fd_sc_hd__decap_3
XFILLER_85_656 VGND VGND VPWR VPWR sky130_fd_sc_hd__decap_3
XFILLER_111_293 VGND VGND VPWR VPWR sky130_fd_sc_hd__decap_3
XFILLER_84_144 VGND VGND VPWR VPWR sky130_fd_sc_hd__decap_3
XFILLER_57_358 VGND VGND VPWR VPWR sky130_fd_sc_hd__decap_3
X_5047_ _5114_/B _4617_/B _4617_/C _5100_/A VGND VGND VPWR VPWR _5084_/B sky130_fd_sc_hd__o31ai_2
XFILLER_26_701 VGND VGND VPWR VPWR sky130_fd_sc_hd__decap_3
XFILLER_25_200 VGND VGND VPWR VPWR sky130_fd_sc_hd__fill_1
XFILLER_26_734 VGND VGND VPWR VPWR sky130_fd_sc_hd__fill_1
XFILLER_65_380 VGND VGND VPWR VPWR sky130_fd_sc_hd__decap_3
XFILLER_53_520 VGND VGND VPWR VPWR sky130_fd_sc_hd__fill_1
XFILLER_65_391 VGND VGND VPWR VPWR sky130_fd_sc_hd__fill_1
XFILLER_25_233 VGND VGND VPWR VPWR sky130_fd_sc_hd__decap_3
XTAP_TAPCELL_ROW_36_740 VGND VPWR sky130_fd_sc_hd__tapvpwrvgnd_1
XFILLER_41_715 VGND VGND VPWR VPWR sky130_fd_sc_hd__decap_3
X_6998_ _7370_/CLK _6998_/D _6278_/Y VGND VGND VPWR VPWR _6998_/Q sky130_fd_sc_hd__dfrtp_2
XFILLER_53_597 VGND VGND VPWR VPWR sky130_fd_sc_hd__decap_3
XFILLER_13_439 VGND VGND VPWR VPWR sky130_fd_sc_hd__decap_3
XTAP_TAPCELL_ROW_97_1528 VGND VPWR sky130_fd_sc_hd__tapvpwrvgnd_1
XFILLER_107_500 VGND VGND VPWR VPWR sky130_fd_sc_hd__decap_3
XFILLER_107_511 VGND VGND VPWR VPWR sky130_fd_sc_hd__decap_3
XFILLER_5_638 VGND VGND VPWR VPWR sky130_fd_sc_hd__decap_3
XFILLER_4_115 VGND VGND VPWR VPWR sky130_fd_sc_hd__decap_3
XFILLER_119_393 VGND VGND VPWR VPWR sky130_fd_sc_hd__decap_3
XFILLER_107_544 VGND VGND VPWR VPWR sky130_fd_sc_hd__decap_3
XFILLER_107_588 VGND VGND VPWR VPWR sky130_fd_sc_hd__decap_3
XFILLER_68_11 VGND VGND VPWR VPWR sky130_fd_sc_hd__decap_3
XFILLER_122_525 VGND VGND VPWR VPWR sky130_fd_sc_hd__decap_3
XFILLER_122_536 VGND VGND VPWR VPWR sky130_fd_sc_hd__decap_3
XFILLER_68_44 VGND VGND VPWR VPWR sky130_fd_sc_hd__decap_3
XFILLER_108_95 VGND VGND VPWR VPWR sky130_fd_sc_hd__decap_3
XFILLER_122_569 VGND VGND VPWR VPWR sky130_fd_sc_hd__decap_3
XFILLER_76_601 VGND VGND VPWR VPWR sky130_fd_sc_hd__decap_3
XFILLER_0_365 VGND VGND VPWR VPWR sky130_fd_sc_hd__decap_3
XFILLER_76_634 VGND VGND VPWR VPWR sky130_fd_sc_hd__decap_3
XFILLER_75_111 VGND VGND VPWR VPWR sky130_fd_sc_hd__fill_1
XFILLER_76_645 VGND VGND VPWR VPWR sky130_fd_sc_hd__decap_3
XFILLER_75_122 VGND VGND VPWR VPWR sky130_fd_sc_hd__decap_3
XFILLER_48_336 VGND VGND VPWR VPWR sky130_fd_sc_hd__decap_3
XFILLER_76_678 VGND VGND VPWR VPWR sky130_fd_sc_hd__decap_3
XFILLER_91_615 VGND VGND VPWR VPWR sky130_fd_sc_hd__fill_1
XFILLER_29_561 VGND VGND VPWR VPWR sky130_fd_sc_hd__fill_1
XFILLER_91_626 VGND VGND VPWR VPWR sky130_fd_sc_hd__decap_3
XFILLER_17_712 VGND VGND VPWR VPWR sky130_fd_sc_hd__decap_3
XFILLER_90_114 VGND VGND VPWR VPWR sky130_fd_sc_hd__decap_3
XFILLER_84_65 VGND VGND VPWR VPWR sky130_fd_sc_hd__decap_3
XFILLER_29_583 VGND VGND VPWR VPWR sky130_fd_sc_hd__decap_3
Xplace306 _3640_/X VGND VGND VPWR VPWR _3665_/B sky130_fd_sc_hd__buf_2
XFILLER_75_199 VGND VGND VPWR VPWR sky130_fd_sc_hd__decap_3
XFILLER_56_380 VGND VGND VPWR VPWR sky130_fd_sc_hd__decap_3
Xplace317 _4537_/X VGND VGND VPWR VPWR _4595_/B sky130_fd_sc_hd__buf_2
XFILLER_91_659 VGND VGND VPWR VPWR sky130_fd_sc_hd__decap_3
Xplace328 _3358_/X VGND VGND VPWR VPWR _4601_/S sky130_fd_sc_hd__buf_2
XFILLER_84_98 VGND VGND VPWR VPWR sky130_fd_sc_hd__decap_3
XFILLER_16_233 VGND VGND VPWR VPWR sky130_fd_sc_hd__decap_3
XTAP_TAPCELL_ROW_106_1646 VGND VPWR sky130_fd_sc_hd__tapvpwrvgnd_1
Xplace339 _3591_/A VGND VGND VPWR VPWR _4376_/A sky130_fd_sc_hd__buf_2
XFILLER_44_553 VGND VGND VPWR VPWR sky130_fd_sc_hd__decap_3
XFILLER_32_704 VGND VGND VPWR VPWR sky130_fd_sc_hd__decap_3
XFILLER_44_586 VGND VGND VPWR VPWR sky130_fd_sc_hd__fill_2
XFILLER_71_372 VGND VGND VPWR VPWR sky130_fd_sc_hd__decap_3
XFILLER_31_214 VGND VGND VPWR VPWR sky130_fd_sc_hd__decap_3
XFILLER_16_299 VGND VGND VPWR VPWR sky130_fd_sc_hd__decap_3
XTAP_TAPCELL_ROW_14_445 VGND VPWR sky130_fd_sc_hd__tapvpwrvgnd_1
XFILLER_31_269 VGND VGND VPWR VPWR sky130_fd_sc_hd__decap_3
XFILLER_12_461 VGND VGND VPWR VPWR sky130_fd_sc_hd__decap_3
XFILLER_8_421 VGND VGND VPWR VPWR sky130_fd_sc_hd__decap_3
XFILLER_33_80 VGND VGND VPWR VPWR sky130_fd_sc_hd__fill_1
XFILLER_12_483 VGND VGND VPWR VPWR sky130_fd_sc_hd__fill_1
XFILLER_69_6 VGND VGND VPWR VPWR sky130_fd_sc_hd__decap_3
XFILLER_99_715 VGND VGND VPWR VPWR sky130_fd_sc_hd__decap_3
XTAP_TAPCELL_ROW_117_1786 VGND VPWR sky130_fd_sc_hd__tapvpwrvgnd_1
XFILLER_4_660 VGND VGND VPWR VPWR sky130_fd_sc_hd__decap_3
XFILLER_113_503 VGND VGND VPWR VPWR sky130_fd_sc_hd__fill_1
X_3300_ _6979_/Q VGND VGND VPWR VPWR _4467_/A sky130_fd_sc_hd__inv_2
XFILLER_113_514 VGND VGND VPWR VPWR sky130_fd_sc_hd__decap_3
X_4280_ _7222_/Q _3377_/X _3366_/X _7158_/Q _4279_/X VGND VGND VPWR VPWR _4280_/X
+ sky130_fd_sc_hd__a221o_2
XFILLER_4_693 VGND VGND VPWR VPWR sky130_fd_sc_hd__decap_3
XFILLER_113_547 VGND VGND VPWR VPWR sky130_fd_sc_hd__decap_3
XFILLER_98_247 VGND VGND VPWR VPWR sky130_fd_sc_hd__decap_3
XFILLER_3_181 VGND VGND VPWR VPWR sky130_fd_sc_hd__decap_3
XFILLER_101_709 VGND VGND VPWR VPWR sky130_fd_sc_hd__decap_3
XFILLER_67_612 VGND VGND VPWR VPWR sky130_fd_sc_hd__decap_3
XFILLER_67_623 VGND VGND VPWR VPWR sky130_fd_sc_hd__decap_3
XFILLER_121_591 VGND VGND VPWR VPWR sky130_fd_sc_hd__decap_3
XFILLER_67_656 VGND VGND VPWR VPWR sky130_fd_sc_hd__decap_3
XFILLER_94_442 VGND VGND VPWR VPWR sky130_fd_sc_hd__decap_3
XFILLER_82_604 VGND VGND VPWR VPWR sky130_fd_sc_hd__decap_3
XFILLER_39_369 VGND VGND VPWR VPWR sky130_fd_sc_hd__fill_2
XFILLER_82_637 VGND VGND VPWR VPWR sky130_fd_sc_hd__decap_3
X_6921_ _7215_/CLK _6921_/D VGND VGND VPWR VPWR _6921_/Q sky130_fd_sc_hd__dfxtp_2
XFILLER_66_188 VGND VGND VPWR VPWR sky130_fd_sc_hd__decap_3
XFILLER_82_648 VGND VGND VPWR VPWR sky130_fd_sc_hd__decap_3
XFILLER_54_339 VGND VGND VPWR VPWR sky130_fd_sc_hd__decap_3
XFILLER_47_380 VGND VGND VPWR VPWR sky130_fd_sc_hd__decap_3
X_6852_ _6942_/CLK _6852_/D VGND VGND VPWR VPWR _6852_/Q sky130_fd_sc_hd__dfxtp_2
XFILLER_81_169 VGND VGND VPWR VPWR sky130_fd_sc_hd__fill_2
XFILLER_23_715 VGND VGND VPWR VPWR sky130_fd_sc_hd__decap_3
XTAP_TAPCELL_ROW_81_1318 VGND VPWR sky130_fd_sc_hd__tapvpwrvgnd_1
XFILLER_90_681 VGND VGND VPWR VPWR sky130_fd_sc_hd__decap_3
Xfanout18 _6662_/A VGND VGND VPWR VPWR _6660_/A sky130_fd_sc_hd__buf_2
XFILLER_62_383 VGND VGND VPWR VPWR sky130_fd_sc_hd__fill_2
XFILLER_35_597 VGND VGND VPWR VPWR sky130_fd_sc_hd__decap_3
Xfanout29 _6370_/A VGND VGND VPWR VPWR _6635_/A sky130_fd_sc_hd__buf_2
XFILLER_22_225 VGND VGND VPWR VPWR sky130_fd_sc_hd__fill_1
X_6783_ _6942_/CLK _6783_/D VGND VGND VPWR VPWR _6783_/Q sky130_fd_sc_hd__dfxtp_2
XFILLER_22_247 VGND VGND VPWR VPWR sky130_fd_sc_hd__decap_3
XFILLER_50_567 VGND VGND VPWR VPWR sky130_fd_sc_hd__fill_1
XFILLER_50_589 VGND VGND VPWR VPWR sky130_fd_sc_hd__decap_3
X_5665_ _5665_/A _5665_/B _5665_/C _5665_/D VGND VGND VPWR VPWR _5666_/B sky130_fd_sc_hd__and4_2
XFILLER_30_291 VGND VGND VPWR VPWR sky130_fd_sc_hd__decap_3
X_7404_ _7404_/CLK _7404_/D _6684_/Y VGND VGND VPWR VPWR _7404_/Q sky130_fd_sc_hd__dfrtp_2
X_4616_ _3547_/A _3547_/B _4614_/X _4615_/Y VGND VGND VPWR VPWR _4617_/C sky130_fd_sc_hd__a31o_2
XPHY_EDGE_ROW_111_Right_111 VGND VGND VPWR VPWR sky130_fd_sc_hd__decap_3
XFILLER_116_330 VGND VGND VPWR VPWR sky130_fd_sc_hd__fill_1
X_7335_ _7371_/CLK _7335_/D _6615_/Y VGND VGND VPWR VPWR _7335_/Q sky130_fd_sc_hd__dfrtp_2
XFILLER_2_608 VGND VGND VPWR VPWR sky130_fd_sc_hd__decap_3
XFILLER_116_374 VGND VGND VPWR VPWR sky130_fd_sc_hd__decap_3
X_7266_ _7362_/CLK _7266_/D _6546_/Y VGND VGND VPWR VPWR _7266_/Q sky130_fd_sc_hd__dfrtp_2
XFILLER_89_225 VGND VGND VPWR VPWR sky130_fd_sc_hd__decap_3
XTAP_TAPCELL_ROW_92_1458 VGND VPWR sky130_fd_sc_hd__tapvpwrvgnd_1
X_4478_ _4478_/A0 _7308_/Q _4488_/S VGND VGND VPWR VPWR _7340_/D sky130_fd_sc_hd__mux2_2
XFILLER_104_536 VGND VGND VPWR VPWR sky130_fd_sc_hd__decap_3
XTAP_TAPCELL_ROW_92_1469 VGND VPWR sky130_fd_sc_hd__tapvpwrvgnd_1
XFILLER_89_258 VGND VGND VPWR VPWR sky130_fd_sc_hd__decap_3
XFILLER_104_569 VGND VGND VPWR VPWR sky130_fd_sc_hd__decap_3
X_3429_ _3429_/A _3429_/B VGND VGND VPWR VPWR _3429_/X sky130_fd_sc_hd__or2_2
X_7197_ _7362_/CLK _7197_/D _6477_/Y VGND VGND VPWR VPWR _7197_/Q sky130_fd_sc_hd__dfrtp_2
XFILLER_58_623 VGND VGND VPWR VPWR sky130_fd_sc_hd__decap_3
XFILLER_57_100 VGND VGND VPWR VPWR sky130_fd_sc_hd__decap_3
XFILLER_38_25 VGND VGND VPWR VPWR sky130_fd_sc_hd__decap_3
Xhold1110 _7303_/Q VGND VGND VPWR VPWR _4554_/A sky130_fd_sc_hd__dlygate4sd3_1
XFILLER_58_645 VGND VGND VPWR VPWR sky130_fd_sc_hd__decap_3
XFILLER_100_731 VGND VGND VPWR VPWR sky130_fd_sc_hd__decap_3
Xhold1121 _7332_/Q VGND VGND VPWR VPWR _4495_/A0 sky130_fd_sc_hd__dlygate4sd3_1
XFILLER_57_122 VGND VGND VPWR VPWR sky130_fd_sc_hd__decap_3
Xhold1132 _7289_/Q VGND VGND VPWR VPWR _4583_/A sky130_fd_sc_hd__dlygate4sd3_1
Xhold1143 _7121_/Q VGND VGND VPWR VPWR _5425_/A0 sky130_fd_sc_hd__dlygate4sd3_1
XFILLER_58_678 VGND VGND VPWR VPWR sky130_fd_sc_hd__decap_3
XFILLER_57_155 VGND VGND VPWR VPWR sky130_fd_sc_hd__decap_3
Xhold1154 _7158_/Q VGND VGND VPWR VPWR _5346_/A0 sky130_fd_sc_hd__dlygate4sd3_1
Xhold1165 _7397_/Q VGND VGND VPWR VPWR _3754_/A1 sky130_fd_sc_hd__dlygate4sd3_1
XFILLER_45_317 VGND VGND VPWR VPWR sky130_fd_sc_hd__fill_1
Xhold1176 _7298_/Q VGND VGND VPWR VPWR _4565_/A sky130_fd_sc_hd__dlygate4sd3_1
XFILLER_85_486 VGND VGND VPWR VPWR sky130_fd_sc_hd__decap_3
XFILLER_73_626 VGND VGND VPWR VPWR sky130_fd_sc_hd__decap_3
XFILLER_72_103 VGND VGND VPWR VPWR sky130_fd_sc_hd__decap_3
Xhold1187 _7012_/Q VGND VGND VPWR VPWR _5632_/A sky130_fd_sc_hd__dlygate4sd3_1
XFILLER_57_188 VGND VGND VPWR VPWR sky130_fd_sc_hd__decap_3
Xhold1198 _6699_/Q VGND VGND VPWR VPWR _5699_/A1 sky130_fd_sc_hd__dlygate4sd3_1
XFILLER_73_659 VGND VGND VPWR VPWR sky130_fd_sc_hd__decap_3
XFILLER_72_147 VGND VGND VPWR VPWR sky130_fd_sc_hd__decap_3
XFILLER_26_542 VGND VGND VPWR VPWR sky130_fd_sc_hd__fill_2
XFILLER_54_35 VGND VGND VPWR VPWR sky130_fd_sc_hd__fill_2
XFILLER_14_704 VGND VGND VPWR VPWR sky130_fd_sc_hd__decap_3
XFILLER_26_586 VGND VGND VPWR VPWR sky130_fd_sc_hd__fill_2
XFILLER_13_225 VGND VGND VPWR VPWR sky130_fd_sc_hd__decap_3
XFILLER_80_180 VGND VGND VPWR VPWR sky130_fd_sc_hd__decap_3
XFILLER_110_41 VGND VGND VPWR VPWR sky130_fd_sc_hd__decap_3
XFILLER_13_258 VGND VGND VPWR VPWR sky130_fd_sc_hd__fill_1
XFILLER_70_12 VGND VGND VPWR VPWR sky130_fd_sc_hd__decap_3
XFILLER_41_589 VGND VGND VPWR VPWR sky130_fd_sc_hd__decap_3
XFILLER_110_85 VGND VGND VPWR VPWR sky130_fd_sc_hd__fill_2
XTAP_TAPCELL_ROW_11_404 VGND VPWR sky130_fd_sc_hd__tapvpwrvgnd_1
XTAP_TAPCELL_ROW_101_1576 VGND VPWR sky130_fd_sc_hd__tapvpwrvgnd_1
XTAP_TAPCELL_ROW_11_415 VGND VPWR sky130_fd_sc_hd__tapvpwrvgnd_1
XFILLER_5_413 VGND VGND VPWR VPWR sky130_fd_sc_hd__decap_3
XFILLER_119_72 VGND VGND VPWR VPWR sky130_fd_sc_hd__decap_3
XFILLER_107_330 VGND VGND VPWR VPWR sky130_fd_sc_hd__decap_3
XTAP_TAPCELL_ROW_56_1000 VGND VPWR sky130_fd_sc_hd__tapvpwrvgnd_1
XFILLER_107_385 VGND VGND VPWR VPWR sky130_fd_sc_hd__decap_3
XFILLER_79_87 VGND VGND VPWR VPWR sky130_fd_sc_hd__decap_3
XFILLER_79_98 VGND VGND VPWR VPWR sky130_fd_sc_hd__decap_3
XFILLER_96_707 VGND VGND VPWR VPWR sky130_fd_sc_hd__decap_3
XFILLER_1_641 VGND VGND VPWR VPWR sky130_fd_sc_hd__decap_3
XFILLER_122_355 VGND VGND VPWR VPWR sky130_fd_sc_hd__decap_3
XFILLER_49_612 VGND VGND VPWR VPWR sky130_fd_sc_hd__decap_3
XFILLER_95_228 VGND VGND VPWR VPWR sky130_fd_sc_hd__decap_3
XFILLER_49_623 VGND VGND VPWR VPWR sky130_fd_sc_hd__decap_3
XFILLER_1_685 VGND VGND VPWR VPWR sky130_fd_sc_hd__decap_3
XFILLER_110_539 VGND VGND VPWR VPWR sky130_fd_sc_hd__decap_3
XFILLER_88_280 VGND VGND VPWR VPWR sky130_fd_sc_hd__decap_3
XFILLER_103_591 VGND VGND VPWR VPWR sky130_fd_sc_hd__decap_3
XFILLER_49_656 VGND VGND VPWR VPWR sky130_fd_sc_hd__decap_3
XFILLER_48_144 VGND VGND VPWR VPWR sky130_fd_sc_hd__fill_2
XFILLER_64_604 VGND VGND VPWR VPWR sky130_fd_sc_hd__decap_3
XFILLER_91_401 VGND VGND VPWR VPWR sky130_fd_sc_hd__decap_3
XFILLER_48_166 VGND VGND VPWR VPWR sky130_fd_sc_hd__decap_3
XTAP_TAPCELL_ROW_19_515 VGND VPWR sky130_fd_sc_hd__tapvpwrvgnd_1
XFILLER_91_423 VGND VGND VPWR VPWR sky130_fd_sc_hd__decap_3
XFILLER_64_637 VGND VGND VPWR VPWR sky130_fd_sc_hd__decap_3
XFILLER_64_648 VGND VGND VPWR VPWR sky130_fd_sc_hd__decap_3
XFILLER_36_339 VGND VGND VPWR VPWR sky130_fd_sc_hd__decap_3
XFILLER_29_380 VGND VGND VPWR VPWR sky130_fd_sc_hd__fill_2
XFILLER_29_391 VGND VGND VPWR VPWR sky130_fd_sc_hd__fill_1
XTAP_TAPCELL_ROW_67_1140 VGND VPWR sky130_fd_sc_hd__tapvpwrvgnd_1
XFILLER_91_467 VGND VGND VPWR VPWR sky130_fd_sc_hd__decap_3
XTAP_TAPCELL_ROW_47_879 VGND VPWR sky130_fd_sc_hd__tapvpwrvgnd_1
XFILLER_63_169 VGND VGND VPWR VPWR sky130_fd_sc_hd__decap_3
XFILLER_17_564 VGND VGND VPWR VPWR sky130_fd_sc_hd__decap_3
XFILLER_32_501 VGND VGND VPWR VPWR sky130_fd_sc_hd__decap_3
XFILLER_72_681 VGND VGND VPWR VPWR sky130_fd_sc_hd__decap_3
XFILLER_17_597 VGND VGND VPWR VPWR sky130_fd_sc_hd__decap_3
XFILLER_20_707 VGND VGND VPWR VPWR sky130_fd_sc_hd__decap_3
X_3780_ _6967_/Q _3661_/X _3840_/A2 _6955_/Q VGND VGND VPWR VPWR _3780_/X sky130_fd_sc_hd__a22o_2
XFILLER_32_589 VGND VGND VPWR VPWR sky130_fd_sc_hd__decap_3
XTAP_TAPCELL_ROW_119_1815 VGND VPWR sky130_fd_sc_hd__tapvpwrvgnd_1
XFILLER_12_291 VGND VGND VPWR VPWR sky130_fd_sc_hd__fill_2
XFILLER_118_628 VGND VGND VPWR VPWR sky130_fd_sc_hd__decap_3
XFILLER_8_262 VGND VGND VPWR VPWR sky130_fd_sc_hd__decap_3
XFILLER_117_105 VGND VGND VPWR VPWR sky130_fd_sc_hd__decap_3
XFILLER_67_3 VGND VGND VPWR VPWR sky130_fd_sc_hd__decap_3
X_4401_ _7274_/Q _4437_/A2 _4430_/A2 _7242_/Q _4400_/X VGND VGND VPWR VPWR _4401_/X
+ sky130_fd_sc_hd__a221o_2
Xoutput504 _3449_/A VGND VGND VPWR VPWR instruction_out[22] sky130_fd_sc_hd__clkdlybuf4s25_1
X_5381_ _5381_/A0 _4864_/X _5383_/S VGND VGND VPWR VPWR _7142_/D sky130_fd_sc_hd__mux2_2
Xoutput515 _5643_/X VGND VGND VPWR VPWR instruction_out[5] sky130_fd_sc_hd__clkdlybuf4s25_1
XFILLER_99_501 VGND VGND VPWR VPWR sky130_fd_sc_hd__decap_3
XTAP_TAPCELL_ROW_78_1280 VGND VPWR sky130_fd_sc_hd__tapvpwrvgnd_1
Xoutput526 _6992_/Q VGND VGND VPWR VPWR pc_out[15] sky130_fd_sc_hd__clkdlybuf4s25_1
Xoutput537 _7002_/Q VGND VGND VPWR VPWR pc_out[25] sky130_fd_sc_hd__clkdlybuf4s25_1
X_7120_ _7325_/CLK _7120_/D _6400_/Y VGND VGND VPWR VPWR _7120_/Q sky130_fd_sc_hd__dfrtp_2
X_4332_ _7191_/Q _3996_/S _3380_/Y _7383_/Q _4331_/X VGND VGND VPWR VPWR _4332_/X
+ sky130_fd_sc_hd__a221o_2
Xoutput548 _5670_/A VGND VGND VPWR VPWR pc_out[6] sky130_fd_sc_hd__clkdlybuf4s25_1
XFILLER_99_556 VGND VGND VPWR VPWR sky130_fd_sc_hd__decap_3
XFILLER_113_333 VGND VGND VPWR VPWR sky130_fd_sc_hd__decap_3
XFILLER_99_567 VGND VGND VPWR VPWR sky130_fd_sc_hd__decap_3
X_7051_ _7368_/CLK _7051_/D _6331_/Y VGND VGND VPWR VPWR _7051_/Q sky130_fd_sc_hd__dfrtp_2
XFILLER_87_718 VGND VGND VPWR VPWR sky130_fd_sc_hd__decap_3
X_4263_ _7134_/Q _4348_/B1 _4261_/X _4262_/X VGND VGND VPWR VPWR _4264_/B sky130_fd_sc_hd__a211o_2
XFILLER_87_729 VGND VGND VPWR VPWR sky130_fd_sc_hd__decap_3
XFILLER_115_19 VGND VGND VPWR VPWR sky130_fd_sc_hd__decap_3
XFILLER_86_206 VGND VGND VPWR VPWR sky130_fd_sc_hd__decap_3
XFILLER_113_377 VGND VGND VPWR VPWR sky130_fd_sc_hd__decap_3
XFILLER_86_239 VGND VGND VPWR VPWR sky130_fd_sc_hd__decap_3
XFILLER_113_399 VGND VGND VPWR VPWR sky130_fd_sc_hd__decap_3
XFILLER_67_420 VGND VGND VPWR VPWR sky130_fd_sc_hd__decap_3
XFILLER_39_111 VGND VGND VPWR VPWR sky130_fd_sc_hd__fill_1
X_4194_ _7231_/Q _4414_/A2 _4422_/A2 _7017_/Q _4193_/X VGND VGND VPWR VPWR _4194_/X
+ sky130_fd_sc_hd__a221o_2
XFILLER_55_615 VGND VGND VPWR VPWR sky130_fd_sc_hd__fill_1
XFILLER_39_166 VGND VGND VPWR VPWR sky130_fd_sc_hd__fill_2
XFILLER_55_626 VGND VGND VPWR VPWR sky130_fd_sc_hd__decap_3
XFILLER_27_317 VGND VGND VPWR VPWR sky130_fd_sc_hd__decap_3
XFILLER_67_497 VGND VGND VPWR VPWR sky130_fd_sc_hd__decap_3
XFILLER_39_188 VGND VGND VPWR VPWR sky130_fd_sc_hd__decap_3
XFILLER_94_294 VGND VGND VPWR VPWR sky130_fd_sc_hd__decap_3
XFILLER_55_659 VGND VGND VPWR VPWR sky130_fd_sc_hd__decap_3
XFILLER_70_607 VGND VGND VPWR VPWR sky130_fd_sc_hd__decap_3
X_6904_ _6965_/CLK _6904_/D VGND VGND VPWR VPWR _6904_/Q sky130_fd_sc_hd__dfxtp_2
XFILLER_54_169 VGND VGND VPWR VPWR sky130_fd_sc_hd__decap_3
XFILLER_42_309 VGND VGND VPWR VPWR sky130_fd_sc_hd__fill_1
XFILLER_82_489 VGND VGND VPWR VPWR sky130_fd_sc_hd__decap_3
XFILLER_24_16 VGND VGND VPWR VPWR sky130_fd_sc_hd__decap_3
X_6835_ _6967_/CLK _6835_/D VGND VGND VPWR VPWR _6835_/Q sky130_fd_sc_hd__dfxtp_2
XFILLER_23_545 VGND VGND VPWR VPWR sky130_fd_sc_hd__fill_2
XFILLER_23_556 VGND VGND VPWR VPWR sky130_fd_sc_hd__decap_3
XFILLER_50_342 VGND VGND VPWR VPWR sky130_fd_sc_hd__decap_3
XFILLER_11_718 VGND VGND VPWR VPWR sky130_fd_sc_hd__decap_3
X_6766_ _6960_/CLK _6766_/D VGND VGND VPWR VPWR _6766_/Q sky130_fd_sc_hd__dfxtp_2
XFILLER_23_589 VGND VGND VPWR VPWR sky130_fd_sc_hd__decap_3
XFILLER_11_729 VGND VGND VPWR VPWR sky130_fd_sc_hd__decap_3
XFILLER_50_375 VGND VGND VPWR VPWR sky130_fd_sc_hd__decap_3
X_5717_ _7364_/Q hold909/X _5737_/S VGND VGND VPWR VPWR _6708_/D sky130_fd_sc_hd__mux2_2
XFILLER_109_606 VGND VGND VPWR VPWR sky130_fd_sc_hd__decap_3
X_6697_ _6926_/CLK _6697_/D VGND VGND VPWR VPWR _6697_/Q sky130_fd_sc_hd__dfxtp_2
XFILLER_109_617 VGND VGND VPWR VPWR sky130_fd_sc_hd__decap_3
XFILLER_108_116 VGND VGND VPWR VPWR sky130_fd_sc_hd__decap_3
X_5648_ _5648_/A _5648_/B VGND VGND VPWR VPWR _5649_/A sky130_fd_sc_hd__or2_2
XFILLER_40_37 VGND VGND VPWR VPWR sky130_fd_sc_hd__fill_1
XFILLER_108_138 VGND VGND VPWR VPWR sky130_fd_sc_hd__fill_2
XFILLER_117_650 VGND VGND VPWR VPWR sky130_fd_sc_hd__decap_3
X_5579_ hold993/X _5045_/X _5581_/S VGND VGND VPWR VPWR _7039_/D sky130_fd_sc_hd__mux2_2
X_7318_ _7318_/CLK _7318_/D _6598_/Y VGND VGND VPWR VPWR _7318_/Q sky130_fd_sc_hd__dfrtp_2
XFILLER_2_427 VGND VGND VPWR VPWR sky130_fd_sc_hd__decap_3
XFILLER_117_694 VGND VGND VPWR VPWR sky130_fd_sc_hd__decap_3
XFILLER_116_193 VGND VGND VPWR VPWR sky130_fd_sc_hd__decap_3
XFILLER_78_707 VGND VGND VPWR VPWR sky130_fd_sc_hd__decap_3
XFILLER_104_344 VGND VGND VPWR VPWR sky130_fd_sc_hd__decap_3
X_7249_ _7352_/CLK _7249_/D _6529_/Y VGND VGND VPWR VPWR _7249_/Q sky130_fd_sc_hd__dfrtp_2
XFILLER_77_217 VGND VGND VPWR VPWR sky130_fd_sc_hd__decap_3
XFILLER_104_377 VGND VGND VPWR VPWR sky130_fd_sc_hd__decap_3
XFILLER_77_228 VGND VGND VPWR VPWR sky130_fd_sc_hd__fill_1
XFILLER_77_239 VGND VGND VPWR VPWR sky130_fd_sc_hd__decap_3
XFILLER_105_30 VGND VGND VPWR VPWR sky130_fd_sc_hd__decap_3
XFILLER_58_453 VGND VGND VPWR VPWR sky130_fd_sc_hd__decap_3
XFILLER_85_250 VGND VGND VPWR VPWR sky130_fd_sc_hd__decap_3
XFILLER_105_74 VGND VGND VPWR VPWR sky130_fd_sc_hd__decap_3
XFILLER_46_626 VGND VGND VPWR VPWR sky130_fd_sc_hd__decap_3
XFILLER_73_412 VGND VGND VPWR VPWR sky130_fd_sc_hd__fill_1
XFILLER_65_34 VGND VGND VPWR VPWR sky130_fd_sc_hd__fill_1
XFILLER_100_583 VGND VGND VPWR VPWR sky130_fd_sc_hd__decap_3
XFILLER_46_648 VGND VGND VPWR VPWR sky130_fd_sc_hd__decap_3
XFILLER_18_339 VGND VGND VPWR VPWR sky130_fd_sc_hd__fill_1
XFILLER_45_147 VGND VGND VPWR VPWR sky130_fd_sc_hd__decap_3
XFILLER_45_169 VGND VGND VPWR VPWR sky130_fd_sc_hd__decap_3
XFILLER_61_629 VGND VGND VPWR VPWR sky130_fd_sc_hd__decap_3
XTAP_TAPCELL_ROW_103_1605 VGND VPWR sky130_fd_sc_hd__tapvpwrvgnd_1
XTAP_TAPCELL_ROW_44_838 VGND VPWR sky130_fd_sc_hd__tapvpwrvgnd_1
XFILLER_54_681 VGND VGND VPWR VPWR sky130_fd_sc_hd__decap_3
XFILLER_121_51 VGND VGND VPWR VPWR sky130_fd_sc_hd__decap_3
XFILLER_26_383 VGND VGND VPWR VPWR sky130_fd_sc_hd__decap_3
XFILLER_14_523 VGND VGND VPWR VPWR sky130_fd_sc_hd__fill_1
XFILLER_121_84 VGND VGND VPWR VPWR sky130_fd_sc_hd__decap_3
XFILLER_41_353 VGND VGND VPWR VPWR sky130_fd_sc_hd__fill_2
XFILLER_14_567 VGND VGND VPWR VPWR sky130_fd_sc_hd__decap_3
XFILLER_14_589 VGND VGND VPWR VPWR sky130_fd_sc_hd__decap_3
XTAP_TAPCELL_ROW_24_573 VGND VPWR sky130_fd_sc_hd__tapvpwrvgnd_1
XTAP_TAPCELL_ROW_24_584 VGND VPWR sky130_fd_sc_hd__tapvpwrvgnd_1
XTAP_TAPCELL_ROW_62_1070 VGND VPWR sky130_fd_sc_hd__tapvpwrvgnd_1
XFILLER_6_722 VGND VGND VPWR VPWR sky130_fd_sc_hd__decap_3
XFILLER_115_609 VGND VGND VPWR VPWR sky130_fd_sc_hd__decap_3
XFILLER_5_254 VGND VGND VPWR VPWR sky130_fd_sc_hd__decap_3
XFILLER_108_672 VGND VGND VPWR VPWR sky130_fd_sc_hd__decap_3
XFILLER_5_276 VGND VGND VPWR VPWR sky130_fd_sc_hd__decap_3
XTAP_TAPCELL_ROW_114_1745 VGND VPWR sky130_fd_sc_hd__tapvpwrvgnd_1
XFILLER_5_287 VGND VGND VPWR VPWR sky130_fd_sc_hd__decap_3
XFILLER_30_81 VGND VGND VPWR VPWR sky130_fd_sc_hd__decap_3
XFILLER_123_620 VGND VGND VPWR VPWR sky130_fd_sc_hd__fill_1
XFILLER_107_193 VGND VGND VPWR VPWR sky130_fd_sc_hd__decap_3
XFILLER_123_653 VGND VGND VPWR VPWR sky130_fd_sc_hd__decap_3
XFILLER_96_504 VGND VGND VPWR VPWR sky130_fd_sc_hd__decap_3
XFILLER_69_718 VGND VGND VPWR VPWR sky130_fd_sc_hd__decap_3
XFILLER_122_141 VGND VGND VPWR VPWR sky130_fd_sc_hd__decap_3
XFILLER_69_729 VGND VGND VPWR VPWR sky130_fd_sc_hd__decap_3
XFILLER_68_206 VGND VGND VPWR VPWR sky130_fd_sc_hd__decap_3
XFILLER_96_548 VGND VGND VPWR VPWR sky130_fd_sc_hd__decap_3
XFILLER_68_239 VGND VGND VPWR VPWR sky130_fd_sc_hd__fill_1
XFILLER_1_493 VGND VGND VPWR VPWR sky130_fd_sc_hd__decap_3
XFILLER_110_347 VGND VGND VPWR VPWR sky130_fd_sc_hd__decap_3
XFILLER_92_710 VGND VGND VPWR VPWR sky130_fd_sc_hd__decap_3
XFILLER_37_615 VGND VGND VPWR VPWR sky130_fd_sc_hd__fill_1
XFILLER_37_626 VGND VGND VPWR VPWR sky130_fd_sc_hd__decap_3
XFILLER_49_497 VGND VGND VPWR VPWR sky130_fd_sc_hd__decap_3
XFILLER_37_659 VGND VGND VPWR VPWR sky130_fd_sc_hd__decap_3
XFILLER_91_231 VGND VGND VPWR VPWR sky130_fd_sc_hd__decap_3
XFILLER_64_456 VGND VGND VPWR VPWR sky130_fd_sc_hd__decap_3
XFILLER_24_309 VGND VGND VPWR VPWR sky130_fd_sc_hd__decap_3
X_4950_ _4950_/A _4950_/B VGND VGND VPWR VPWR _4950_/Y sky130_fd_sc_hd__nor2_2
XFILLER_91_275 VGND VGND VPWR VPWR sky130_fd_sc_hd__decap_3
XFILLER_64_489 VGND VGND VPWR VPWR sky130_fd_sc_hd__decap_3
XFILLER_17_361 VGND VGND VPWR VPWR sky130_fd_sc_hd__decap_3
X_3901_ hold950/X _5104_/A _3900_/Y VGND VGND VPWR VPWR _7381_/D sky130_fd_sc_hd__a21bo_2
X_4881_ _6998_/Q _4912_/A VGND VGND VPWR VPWR _4882_/B sky130_fd_sc_hd__or2_2
XFILLER_60_640 VGND VGND VPWR VPWR sky130_fd_sc_hd__decap_3
XFILLER_60_651 VGND VGND VPWR VPWR sky130_fd_sc_hd__decap_3
X_6620_ _6620_/A VGND VGND VPWR VPWR _6620_/Y sky130_fd_sc_hd__inv_2
X_3832_ _3728_/Y _3824_/X _3826_/X _3735_/X _3831_/X VGND VGND VPWR VPWR _3832_/X
+ sky130_fd_sc_hd__a221o_2
XFILLER_60_684 VGND VGND VPWR VPWR sky130_fd_sc_hd__decap_3
X_6551_ _6553_/A VGND VGND VPWR VPWR _6551_/Y sky130_fd_sc_hd__inv_2
X_3763_ hold933/X _3857_/A2 _3762_/X VGND VGND VPWR VPWR _7395_/D sky130_fd_sc_hd__a21o_2
XFILLER_118_414 VGND VGND VPWR VPWR sky130_fd_sc_hd__decap_3
XFILLER_9_582 VGND VGND VPWR VPWR sky130_fd_sc_hd__decap_3
X_6482_ _6680_/A VGND VGND VPWR VPWR _6482_/Y sky130_fd_sc_hd__inv_2
XFILLER_118_436 VGND VGND VPWR VPWR sky130_fd_sc_hd__decap_3
XFILLER_118_447 VGND VGND VPWR VPWR sky130_fd_sc_hd__decap_3
XFILLER_114_631 VGND VGND VPWR VPWR sky130_fd_sc_hd__decap_3
XFILLER_99_331 VGND VGND VPWR VPWR sky130_fd_sc_hd__decap_3
X_7103_ _7359_/CLK _7103_/D _6383_/Y VGND VGND VPWR VPWR _7103_/Q sky130_fd_sc_hd__dfrtp_2
X_4315_ _4315_/A _4315_/B VGND VGND VPWR VPWR _4361_/A sky130_fd_sc_hd__nand2_2
XFILLER_114_675 VGND VGND VPWR VPWR sky130_fd_sc_hd__decap_3
XFILLER_59_228 VGND VGND VPWR VPWR sky130_fd_sc_hd__decap_3
X_7034_ _7352_/CLK _7034_/D _6314_/Y VGND VGND VPWR VPWR _7034_/Q sky130_fd_sc_hd__dfrtp_2
X_4246_ _7229_/Q _4421_/A2 _4341_/B1 _7133_/Q VGND VGND VPWR VPWR _4246_/X sky130_fd_sc_hd__a22o_2
XFILLER_74_209 VGND VGND VPWR VPWR sky130_fd_sc_hd__fill_1
XFILLER_28_604 VGND VGND VPWR VPWR sky130_fd_sc_hd__decap_3
X_4177_ _7232_/Q _4421_/A2 _4175_/X _4176_/X VGND VGND VPWR VPWR _4177_/X sky130_fd_sc_hd__a211o_2
XFILLER_95_570 VGND VGND VPWR VPWR sky130_fd_sc_hd__decap_3
XFILLER_83_721 VGND VGND VPWR VPWR sky130_fd_sc_hd__decap_3
XFILLER_28_637 VGND VGND VPWR VPWR sky130_fd_sc_hd__decap_3
XFILLER_83_732 VGND VGND VPWR VPWR sky130_fd_sc_hd__decap_3
XFILLER_55_423 VGND VGND VPWR VPWR sky130_fd_sc_hd__decap_3
XFILLER_28_648 VGND VGND VPWR VPWR sky130_fd_sc_hd__decap_3
XFILLER_27_125 VGND VGND VPWR VPWR sky130_fd_sc_hd__decap_3
XFILLER_55_456 VGND VGND VPWR VPWR sky130_fd_sc_hd__decap_3
XFILLER_82_253 VGND VGND VPWR VPWR sky130_fd_sc_hd__decap_3
XFILLER_35_26 VGND VGND VPWR VPWR sky130_fd_sc_hd__decap_3
XFILLER_55_489 VGND VGND VPWR VPWR sky130_fd_sc_hd__decap_3
XFILLER_43_629 VGND VGND VPWR VPWR sky130_fd_sc_hd__decap_3
XFILLER_36_681 VGND VGND VPWR VPWR sky130_fd_sc_hd__decap_3
XFILLER_70_448 VGND VGND VPWR VPWR sky130_fd_sc_hd__fill_1
XFILLER_23_320 VGND VGND VPWR VPWR sky130_fd_sc_hd__fill_2
XFILLER_70_459 VGND VGND VPWR VPWR sky130_fd_sc_hd__decap_3
XFILLER_51_662 VGND VGND VPWR VPWR sky130_fd_sc_hd__decap_3
XFILLER_51_673 VGND VGND VPWR VPWR sky130_fd_sc_hd__decap_3
X_6818_ clkload8/A _6818_/D VGND VGND VPWR VPWR _6818_/Q sky130_fd_sc_hd__dfxtp_2
XFILLER_11_526 VGND VGND VPWR VPWR sky130_fd_sc_hd__decap_3
XFILLER_50_172 VGND VGND VPWR VPWR sky130_fd_sc_hd__decap_3
XFILLER_7_508 VGND VGND VPWR VPWR sky130_fd_sc_hd__fill_1
XFILLER_11_559 VGND VGND VPWR VPWR sky130_fd_sc_hd__fill_1
X_6749_ _6942_/CLK _6749_/D VGND VGND VPWR VPWR _6749_/Q sky130_fd_sc_hd__dfxtp_2
XTAP_TAPCELL_ROW_21_543 VGND VPWR sky130_fd_sc_hd__tapvpwrvgnd_1
XFILLER_109_414 VGND VGND VPWR VPWR sky130_fd_sc_hd__decap_3
XFILLER_3_703 VGND VGND VPWR VPWR sky130_fd_sc_hd__decap_3
XFILLER_105_620 VGND VGND VPWR VPWR sky130_fd_sc_hd__decap_3
XFILLER_117_491 VGND VGND VPWR VPWR sky130_fd_sc_hd__decap_3
XFILLER_2_246 VGND VGND VPWR VPWR sky130_fd_sc_hd__decap_3
XFILLER_105_653 VGND VGND VPWR VPWR sky130_fd_sc_hd__decap_3
XFILLER_78_504 VGND VGND VPWR VPWR sky130_fd_sc_hd__decap_3
XFILLER_104_141 VGND VGND VPWR VPWR sky130_fd_sc_hd__decap_3
XFILLER_120_601 VGND VGND VPWR VPWR sky130_fd_sc_hd__decap_3
XFILLER_105_697 VGND VGND VPWR VPWR sky130_fd_sc_hd__decap_3
XFILLER_76_11 VGND VGND VPWR VPWR sky130_fd_sc_hd__decap_3
XFILLER_120_634 VGND VGND VPWR VPWR sky130_fd_sc_hd__decap_3
XFILLER_116_62 VGND VGND VPWR VPWR sky130_fd_sc_hd__decap_3
XFILLER_78_548 VGND VGND VPWR VPWR sky130_fd_sc_hd__decap_3
XFILLER_120_645 VGND VGND VPWR VPWR sky130_fd_sc_hd__decap_3
XTAP_TAPCELL_ROW_49_908 VGND VPWR sky130_fd_sc_hd__tapvpwrvgnd_1
XFILLER_120_678 VGND VGND VPWR VPWR sky130_fd_sc_hd__decap_3
XFILLER_19_615 VGND VGND VPWR VPWR sky130_fd_sc_hd__fill_1
XFILLER_74_710 VGND VGND VPWR VPWR sky130_fd_sc_hd__decap_3
XFILLER_19_626 VGND VGND VPWR VPWR sky130_fd_sc_hd__decap_3
XFILLER_76_88 VGND VGND VPWR VPWR sky130_fd_sc_hd__decap_3
XFILLER_86_592 VGND VGND VPWR VPWR sky130_fd_sc_hd__decap_3
XFILLER_19_659 VGND VGND VPWR VPWR sky130_fd_sc_hd__decap_3
XTAP_TAPCELL_ROW_29_643 VGND VPWR sky130_fd_sc_hd__tapvpwrvgnd_1
XFILLER_73_231 VGND VGND VPWR VPWR sky130_fd_sc_hd__decap_3
XFILLER_34_607 VGND VGND VPWR VPWR sky130_fd_sc_hd__decap_3
XFILLER_73_264 VGND VGND VPWR VPWR sky130_fd_sc_hd__decap_3
XFILLER_61_415 VGND VGND VPWR VPWR sky130_fd_sc_hd__decap_3
XFILLER_92_54 VGND VGND VPWR VPWR sky130_fd_sc_hd__decap_3
XFILLER_42_640 VGND VGND VPWR VPWR sky130_fd_sc_hd__decap_3
XFILLER_42_651 VGND VGND VPWR VPWR sky130_fd_sc_hd__decap_3
XFILLER_42_684 VGND VGND VPWR VPWR sky130_fd_sc_hd__decap_3
XFILLER_25_92 VGND VGND VPWR VPWR sky130_fd_sc_hd__decap_3
XFILLER_41_172 VGND VGND VPWR VPWR sky130_fd_sc_hd__decap_3
XFILLER_41_183 VGND VGND VPWR VPWR sky130_fd_sc_hd__fill_2
XFILLER_10_581 VGND VGND VPWR VPWR sky130_fd_sc_hd__decap_3
XFILLER_10_592 VGND VGND VPWR VPWR sky130_fd_sc_hd__decap_3
XFILLER_6_563 VGND VGND VPWR VPWR sky130_fd_sc_hd__decap_3
XFILLER_115_406 VGND VGND VPWR VPWR sky130_fd_sc_hd__decap_3
XFILLER_51_6 VGND VGND VPWR VPWR sky130_fd_sc_hd__decap_3
XFILLER_115_439 VGND VGND VPWR VPWR sky130_fd_sc_hd__decap_3
XFILLER_108_480 VGND VGND VPWR VPWR sky130_fd_sc_hd__decap_3
XPHY_EDGE_ROW_102_Left_226 VGND VGND VPWR VPWR sky130_fd_sc_hd__decap_3
XFILLER_123_461 VGND VGND VPWR VPWR sky130_fd_sc_hd__decap_3
XFILLER_111_612 VGND VGND VPWR VPWR sky130_fd_sc_hd__decap_3
XFILLER_96_312 VGND VGND VPWR VPWR sky130_fd_sc_hd__decap_3
XTAP_TAPCELL_ROW_9_390 VGND VPWR sky130_fd_sc_hd__tapvpwrvgnd_1
X_4100_ _7269_/Q _4437_/A2 _4430_/A2 _7237_/Q _4099_/X VGND VGND VPWR VPWR _4100_/X
+ sky130_fd_sc_hd__a221o_2
XFILLER_111_623 VGND VGND VPWR VPWR sky130_fd_sc_hd__decap_3
XFILLER_123_494 VGND VGND VPWR VPWR sky130_fd_sc_hd__decap_3
X_5080_ _5080_/A0 _5079_/X _5080_/S VGND VGND VPWR VPWR _7257_/D sky130_fd_sc_hd__mux2_2
XFILLER_111_656 VGND VGND VPWR VPWR sky130_fd_sc_hd__decap_3
XFILLER_96_356 VGND VGND VPWR VPWR sky130_fd_sc_hd__decap_3
XFILLER_1_290 VGND VGND VPWR VPWR sky130_fd_sc_hd__fill_1
XFILLER_56_209 VGND VGND VPWR VPWR sky130_fd_sc_hd__decap_3
XFILLER_49_261 VGND VGND VPWR VPWR sky130_fd_sc_hd__fill_1
XFILLER_65_721 VGND VGND VPWR VPWR sky130_fd_sc_hd__decap_3
XFILLER_49_272 VGND VGND VPWR VPWR sky130_fd_sc_hd__decap_3
XFILLER_65_732 VGND VGND VPWR VPWR sky130_fd_sc_hd__decap_3
XFILLER_64_242 VGND VGND VPWR VPWR sky130_fd_sc_hd__decap_3
XFILLER_92_562 VGND VGND VPWR VPWR sky130_fd_sc_hd__decap_3
XFILLER_64_253 VGND VGND VPWR VPWR sky130_fd_sc_hd__decap_3
XFILLER_80_713 VGND VGND VPWR VPWR sky130_fd_sc_hd__decap_3
XFILLER_25_629 VGND VGND VPWR VPWR sky130_fd_sc_hd__decap_3
XFILLER_92_595 VGND VGND VPWR VPWR sky130_fd_sc_hd__decap_3
XFILLER_64_286 VGND VGND VPWR VPWR sky130_fd_sc_hd__decap_3
XFILLER_18_681 VGND VGND VPWR VPWR sky130_fd_sc_hd__decap_3
XFILLER_64_297 VGND VGND VPWR VPWR sky130_fd_sc_hd__fill_1
XFILLER_24_139 VGND VGND VPWR VPWR sky130_fd_sc_hd__fill_1
XTAP_TAPCELL_ROW_86_1390 VGND VPWR sky130_fd_sc_hd__tapvpwrvgnd_1
X_4933_ _4933_/A0 _4932_/X _4979_/S VGND VGND VPWR VPWR _7266_/D sky130_fd_sc_hd__mux2_2
XPHY_EDGE_ROW_111_Left_235 VGND VGND VPWR VPWR sky130_fd_sc_hd__decap_3
XFILLER_33_662 VGND VGND VPWR VPWR sky130_fd_sc_hd__decap_3
XFILLER_33_673 VGND VGND VPWR VPWR sky130_fd_sc_hd__decap_3
X_4864_ _4910_/A _4857_/X _4860_/Y _7000_/D _4997_/A1 VGND VGND VPWR VPWR _4864_/X
+ sky130_fd_sc_hd__a32o_2
XFILLER_32_161 VGND VGND VPWR VPWR sky130_fd_sc_hd__decap_3
XANTENNA_13 _4927_/B VGND VGND VPWR VPWR sky130_fd_sc_hd__diode_2
X_3815_ _6928_/Q _3926_/A2 _3925_/A2 _6702_/Q VGND VGND VPWR VPWR _3815_/X sky130_fd_sc_hd__a22o_2
X_6603_ _6603_/A VGND VGND VPWR VPWR _6603_/Y sky130_fd_sc_hd__inv_2
X_4795_ _4795_/A _4795_/B VGND VGND VPWR VPWR _4795_/X sky130_fd_sc_hd__xor2_2
XFILLER_119_712 VGND VGND VPWR VPWR sky130_fd_sc_hd__decap_3
X_6534_ _6596_/A VGND VGND VPWR VPWR _6534_/Y sky130_fd_sc_hd__inv_2
X_3746_ _3746_/A _3746_/B _3746_/C VGND VGND VPWR VPWR _3746_/X sky130_fd_sc_hd__and3_2
XFILLER_9_390 VGND VGND VPWR VPWR sky130_fd_sc_hd__fill_2
XFILLER_21_39 VGND VGND VPWR VPWR sky130_fd_sc_hd__decap_3
XFILLER_118_233 VGND VGND VPWR VPWR sky130_fd_sc_hd__decap_3
X_6465_ _6626_/A VGND VGND VPWR VPWR _6465_/Y sky130_fd_sc_hd__inv_2
X_3677_ _6942_/Q VGND VGND VPWR VPWR _3677_/Y sky130_fd_sc_hd__inv_2
XPHY_EDGE_ROW_120_Left_244 VGND VGND VPWR VPWR sky130_fd_sc_hd__decap_3
X_6396_ _6620_/A VGND VGND VPWR VPWR _6396_/Y sky130_fd_sc_hd__inv_2
XFILLER_102_601 VGND VGND VPWR VPWR sky130_fd_sc_hd__decap_3
XFILLER_99_172 VGND VGND VPWR VPWR sky130_fd_sc_hd__fill_1
XFILLER_102_634 VGND VGND VPWR VPWR sky130_fd_sc_hd__decap_3
XFILLER_102_645 VGND VGND VPWR VPWR sky130_fd_sc_hd__decap_3
X_5278_ hold999/X _5107_/X _5278_/S VGND VGND VPWR VPWR _7191_/D sky130_fd_sc_hd__mux2_2
XFILLER_101_122 VGND VGND VPWR VPWR sky130_fd_sc_hd__decap_3
XTAP_TAPCELL_ROW_89_1419 VGND VPWR sky130_fd_sc_hd__tapvpwrvgnd_1
X_7017_ _7365_/CLK _7017_/D _6297_/Y VGND VGND VPWR VPWR _7017_/Q sky130_fd_sc_hd__dfrtp_2
XFILLER_102_678 VGND VGND VPWR VPWR sky130_fd_sc_hd__decap_3
X_4229_ _7099_/Q _4335_/B1 _4351_/B1 _7131_/Q VGND VGND VPWR VPWR _4229_/X sky130_fd_sc_hd__a22o_2
XFILLER_68_570 VGND VGND VPWR VPWR sky130_fd_sc_hd__decap_3
XFILLER_56_710 VGND VGND VPWR VPWR sky130_fd_sc_hd__decap_3
XFILLER_28_401 VGND VGND VPWR VPWR sky130_fd_sc_hd__fill_2
XFILLER_101_166 VGND VGND VPWR VPWR sky130_fd_sc_hd__fill_2
XFILLER_46_25 VGND VGND VPWR VPWR sky130_fd_sc_hd__decap_3
XFILLER_55_231 VGND VGND VPWR VPWR sky130_fd_sc_hd__decap_3
XFILLER_16_607 VGND VGND VPWR VPWR sky130_fd_sc_hd__decap_3
XFILLER_83_573 VGND VGND VPWR VPWR sky130_fd_sc_hd__decap_3
XFILLER_55_264 VGND VGND VPWR VPWR sky130_fd_sc_hd__decap_3
XTAP_TAPCELL_ROW_26_602 VGND VPWR sky130_fd_sc_hd__tapvpwrvgnd_1
XFILLER_71_724 VGND VGND VPWR VPWR sky130_fd_sc_hd__decap_3
XFILLER_28_489 VGND VGND VPWR VPWR sky130_fd_sc_hd__decap_3
XFILLER_43_426 VGND VGND VPWR VPWR sky130_fd_sc_hd__decap_3
XTAP_TAPCELL_ROW_54_966 VGND VPWR sky130_fd_sc_hd__tapvpwrvgnd_1
XFILLER_24_640 VGND VGND VPWR VPWR sky130_fd_sc_hd__decap_3
XFILLER_70_256 VGND VGND VPWR VPWR sky130_fd_sc_hd__decap_3
XFILLER_24_651 VGND VGND VPWR VPWR sky130_fd_sc_hd__decap_3
XFILLER_70_278 VGND VGND VPWR VPWR sky130_fd_sc_hd__decap_3
XFILLER_62_46 VGND VGND VPWR VPWR sky130_fd_sc_hd__decap_3
XFILLER_30_109 VGND VGND VPWR VPWR sky130_fd_sc_hd__decap_3
XFILLER_24_684 VGND VGND VPWR VPWR sky130_fd_sc_hd__decap_3
XFILLER_51_470 VGND VGND VPWR VPWR sky130_fd_sc_hd__decap_3
XFILLER_23_161 VGND VGND VPWR VPWR sky130_fd_sc_hd__decap_3
XFILLER_11_301 VGND VGND VPWR VPWR sky130_fd_sc_hd__decap_3
XFILLER_23_172 VGND VGND VPWR VPWR sky130_fd_sc_hd__decap_3
XFILLER_11_389 VGND VGND VPWR VPWR sky130_fd_sc_hd__decap_3
XFILLER_109_266 VGND VGND VPWR VPWR sky130_fd_sc_hd__decap_3
XFILLER_3_511 VGND VGND VPWR VPWR sky130_fd_sc_hd__decap_3
XFILLER_3_544 VGND VGND VPWR VPWR sky130_fd_sc_hd__decap_3
XTAP_TAPCELL_ROW_111_1704 VGND VPWR sky130_fd_sc_hd__tapvpwrvgnd_1
XTAP_TAPCELL_ROW_111_1715 VGND VPWR sky130_fd_sc_hd__tapvpwrvgnd_1
XFILLER_87_21 VGND VGND VPWR VPWR sky130_fd_sc_hd__decap_3
XFILLER_3_588 VGND VGND VPWR VPWR sky130_fd_sc_hd__decap_3
XFILLER_78_312 VGND VGND VPWR VPWR sky130_fd_sc_hd__decap_3
XFILLER_38_209 VGND VGND VPWR VPWR sky130_fd_sc_hd__decap_3
XFILLER_93_315 VGND VGND VPWR VPWR sky130_fd_sc_hd__decap_3
XFILLER_120_475 VGND VGND VPWR VPWR sky130_fd_sc_hd__fill_1
XTAP_TAPCELL_ROW_70_1180 VGND VPWR sky130_fd_sc_hd__tapvpwrvgnd_1
XFILLER_120_486 VGND VGND VPWR VPWR sky130_fd_sc_hd__decap_3
XFILLER_47_721 VGND VGND VPWR VPWR sky130_fd_sc_hd__decap_3
XFILLER_93_337 VGND VGND VPWR VPWR sky130_fd_sc_hd__decap_3
XFILLER_47_732 VGND VGND VPWR VPWR sky130_fd_sc_hd__decap_3
XFILLER_46_231 VGND VGND VPWR VPWR sky130_fd_sc_hd__decap_3
XFILLER_46_253 VGND VGND VPWR VPWR sky130_fd_sc_hd__decap_3
XFILLER_62_713 VGND VGND VPWR VPWR sky130_fd_sc_hd__decap_3
XTAP_TAPCELL_ROW_109_1688 VGND VPWR sky130_fd_sc_hd__tapvpwrvgnd_1
XFILLER_74_595 VGND VGND VPWR VPWR sky130_fd_sc_hd__decap_3
XFILLER_61_212 VGND VGND VPWR VPWR sky130_fd_sc_hd__decap_3
XFILLER_46_286 VGND VGND VPWR VPWR sky130_fd_sc_hd__decap_3
XFILLER_61_234 VGND VGND VPWR VPWR sky130_fd_sc_hd__decap_3
XFILLER_34_448 VGND VGND VPWR VPWR sky130_fd_sc_hd__decap_3
XFILLER_36_91 VGND VGND VPWR VPWR sky130_fd_sc_hd__decap_3
XFILLER_61_256 VGND VGND VPWR VPWR sky130_fd_sc_hd__decap_3
XTAP_TAPCELL_ROW_122_1855 VGND VPWR sky130_fd_sc_hd__tapvpwrvgnd_1
XFILLER_15_662 VGND VGND VPWR VPWR sky130_fd_sc_hd__decap_3
XFILLER_61_278 VGND VGND VPWR VPWR sky130_fd_sc_hd__fill_2
XFILLER_15_673 VGND VGND VPWR VPWR sky130_fd_sc_hd__decap_3
XFILLER_14_150 VGND VGND VPWR VPWR sky130_fd_sc_hd__decap_3
XFILLER_99_6 VGND VGND VPWR VPWR sky130_fd_sc_hd__decap_3
XFILLER_30_610 VGND VGND VPWR VPWR sky130_fd_sc_hd__decap_3
XFILLER_30_643 VGND VGND VPWR VPWR sky130_fd_sc_hd__fill_1
XFILLER_30_654 VGND VGND VPWR VPWR sky130_fd_sc_hd__decap_3
X_3600_ _3600_/A VGND VGND VPWR VPWR _3600_/Y sky130_fd_sc_hd__inv_2
XFILLER_30_687 VGND VGND VPWR VPWR sky130_fd_sc_hd__decap_3
XFILLER_116_704 VGND VGND VPWR VPWR sky130_fd_sc_hd__decap_3
Xhold806 _6875_/Q VGND VGND VPWR VPWR _6875_/D sky130_fd_sc_hd__dlygate4sd3_1
Xhold817 _6939_/Q VGND VGND VPWR VPWR _6939_/D sky130_fd_sc_hd__dlygate4sd3_1
Xhold828 _6867_/Q VGND VGND VPWR VPWR _6867_/D sky130_fd_sc_hd__dlygate4sd3_1
Xhold839 _6806_/Q VGND VGND VPWR VPWR _6806_/D sky130_fd_sc_hd__dlygate4sd3_1
X_3462_ _7249_/Q _3358_/X _3459_/X _3461_/X VGND VGND VPWR VPWR _3462_/X sky130_fd_sc_hd__a211o_2
Xmax_cap558 _4200_/A VGND VGND VPWR VPWR _4950_/A sky130_fd_sc_hd__clkbuf_2
Xmax_cap569 _6278_/A VGND VGND VPWR VPWR _6275_/A sky130_fd_sc_hd__buf_2
XFILLER_103_409 VGND VGND VPWR VPWR sky130_fd_sc_hd__fill_2
XFILLER_88_109 VGND VGND VPWR VPWR sky130_fd_sc_hd__decap_3
XFILLER_69_312 VGND VGND VPWR VPWR sky130_fd_sc_hd__decap_3
XFILLER_97_632 VGND VGND VPWR VPWR sky130_fd_sc_hd__decap_3
X_5132_ _5132_/A0 _5131_/X _5159_/S VGND VGND VPWR VPWR _7252_/D sky130_fd_sc_hd__mux2_2
XFILLER_97_665 VGND VGND VPWR VPWR sky130_fd_sc_hd__decap_3
XFILLER_111_442 VGND VGND VPWR VPWR sky130_fd_sc_hd__decap_3
XTAP_TAPCELL_ROW_4_319 VGND VPWR sky130_fd_sc_hd__tapvpwrvgnd_1
XFILLER_97_676 VGND VGND VPWR VPWR sky130_fd_sc_hd__decap_3
X_5063_ hold988/X _5061_/X _5080_/S VGND VGND VPWR VPWR _7258_/D sky130_fd_sc_hd__mux2_2
XFILLER_96_164 VGND VGND VPWR VPWR sky130_fd_sc_hd__decap_3
XFILLER_84_315 VGND VGND VPWR VPWR sky130_fd_sc_hd__decap_3
XFILLER_38_710 VGND VGND VPWR VPWR sky130_fd_sc_hd__decap_3
XFILLER_96_186 VGND VGND VPWR VPWR sky130_fd_sc_hd__decap_3
XFILLER_37_220 VGND VGND VPWR VPWR sky130_fd_sc_hd__decap_3
XFILLER_53_724 VGND VGND VPWR VPWR sky130_fd_sc_hd__decap_3
XFILLER_65_595 VGND VGND VPWR VPWR sky130_fd_sc_hd__decap_3
XFILLER_92_392 VGND VGND VPWR VPWR sky130_fd_sc_hd__decap_3
XFILLER_40_418 VGND VGND VPWR VPWR sky130_fd_sc_hd__fill_2
XTAP_TAPCELL_ROW_51_925 VGND VPWR sky130_fd_sc_hd__tapvpwrvgnd_1
XFILLER_80_587 VGND VGND VPWR VPWR sky130_fd_sc_hd__fill_1
X_4916_ _4916_/A _4916_/B VGND VGND VPWR VPWR _4967_/A sky130_fd_sc_hd__nand2_2
XFILLER_80_598 VGND VGND VPWR VPWR sky130_fd_sc_hd__decap_3
XFILLER_52_289 VGND VGND VPWR VPWR sky130_fd_sc_hd__decap_3
XFILLER_21_610 VGND VGND VPWR VPWR sky130_fd_sc_hd__decap_3
XTAP_TAPCELL_ROW_51_936 VGND VPWR sky130_fd_sc_hd__tapvpwrvgnd_1
XFILLER_21_632 VGND VGND VPWR VPWR sky130_fd_sc_hd__decap_3
X_4847_ _4968_/A _4384_/C _4206_/X VGND VGND VPWR VPWR _4904_/B sky130_fd_sc_hd__a21oi_2
XFILLER_21_665 VGND VGND VPWR VPWR sky130_fd_sc_hd__decap_3
XFILLER_21_676 VGND VGND VPWR VPWR sky130_fd_sc_hd__decap_3
XFILLER_20_153 VGND VGND VPWR VPWR sky130_fd_sc_hd__decap_3
XFILLER_119_520 VGND VGND VPWR VPWR sky130_fd_sc_hd__decap_3
XTAP_TAPCELL_ROW_31_671 VGND VPWR sky130_fd_sc_hd__tapvpwrvgnd_1
XFILLER_20_175 VGND VGND VPWR VPWR sky130_fd_sc_hd__decap_3
X_4778_ _4778_/A _4778_/B VGND VGND VPWR VPWR _4827_/B sky130_fd_sc_hd__and2_2
XFILLER_20_197 VGND VGND VPWR VPWR sky130_fd_sc_hd__decap_3
XFILLER_119_553 VGND VGND VPWR VPWR sky130_fd_sc_hd__decap_3
XFILLER_119_564 VGND VGND VPWR VPWR sky130_fd_sc_hd__decap_3
X_3729_ _6968_/Q _3888_/A2 _3878_/B1 _6962_/Q VGND VGND VPWR VPWR _3729_/X sky130_fd_sc_hd__a22o_2
X_6517_ _6614_/A VGND VGND VPWR VPWR _6517_/Y sky130_fd_sc_hd__inv_2
XFILLER_107_715 VGND VGND VPWR VPWR sky130_fd_sc_hd__decap_3
XFILLER_106_203 VGND VGND VPWR VPWR sky130_fd_sc_hd__decap_3
XFILLER_119_597 VGND VGND VPWR VPWR sky130_fd_sc_hd__decap_3
X_6448_ _6542_/A VGND VGND VPWR VPWR _6448_/Y sky130_fd_sc_hd__inv_2
XFILLER_122_707 VGND VGND VPWR VPWR sky130_fd_sc_hd__decap_3
XFILLER_0_503 VGND VGND VPWR VPWR sky130_fd_sc_hd__fill_1
X_6379_ _6568_/A VGND VGND VPWR VPWR _6379_/Y sky130_fd_sc_hd__inv_2
XFILLER_88_610 VGND VGND VPWR VPWR sky130_fd_sc_hd__decap_3
XFILLER_121_228 VGND VGND VPWR VPWR sky130_fd_sc_hd__fill_1
XFILLER_0_536 VGND VGND VPWR VPWR sky130_fd_sc_hd__decap_3
XFILLER_88_643 VGND VGND VPWR VPWR sky130_fd_sc_hd__fill_1
XFILLER_88_654 VGND VGND VPWR VPWR sky130_fd_sc_hd__decap_3
XFILLER_87_131 VGND VGND VPWR VPWR sky130_fd_sc_hd__decap_3
XFILLER_88_687 VGND VGND VPWR VPWR sky130_fd_sc_hd__decap_3
XFILLER_102_464 VGND VGND VPWR VPWR sky130_fd_sc_hd__decap_3
XFILLER_75_304 VGND VGND VPWR VPWR sky130_fd_sc_hd__decap_3
XFILLER_75_326 VGND VGND VPWR VPWR sky130_fd_sc_hd__decap_3
XFILLER_57_57 VGND VGND VPWR VPWR sky130_fd_sc_hd__decap_3
XFILLER_29_721 VGND VGND VPWR VPWR sky130_fd_sc_hd__decap_3
XFILLER_75_337 VGND VGND VPWR VPWR sky130_fd_sc_hd__fill_2
XFILLER_87_197 VGND VGND VPWR VPWR sky130_fd_sc_hd__decap_3
XFILLER_29_732 VGND VGND VPWR VPWR sky130_fd_sc_hd__decap_3
XFILLER_113_30 VGND VGND VPWR VPWR sky130_fd_sc_hd__decap_3
XFILLER_28_242 VGND VGND VPWR VPWR sky130_fd_sc_hd__decap_3
XFILLER_28_253 VGND VGND VPWR VPWR sky130_fd_sc_hd__decap_3
XFILLER_44_713 VGND VGND VPWR VPWR sky130_fd_sc_hd__decap_3
XFILLER_113_63 VGND VGND VPWR VPWR sky130_fd_sc_hd__decap_3
XTAP_TAPCELL_ROW_39_771 VGND VPWR sky130_fd_sc_hd__tapvpwrvgnd_1
XFILLER_73_12 VGND VGND VPWR VPWR sky130_fd_sc_hd__decap_3
XFILLER_43_201 VGND VGND VPWR VPWR sky130_fd_sc_hd__fill_2
XFILLER_83_370 VGND VGND VPWR VPWR sky130_fd_sc_hd__decap_3
XFILLER_28_286 VGND VGND VPWR VPWR sky130_fd_sc_hd__decap_3
XFILLER_83_381 VGND VGND VPWR VPWR sky130_fd_sc_hd__fill_2
XFILLER_16_437 VGND VGND VPWR VPWR sky130_fd_sc_hd__fill_1
XFILLER_113_96 VGND VGND VPWR VPWR sky130_fd_sc_hd__decap_3
XFILLER_43_234 VGND VGND VPWR VPWR sky130_fd_sc_hd__fill_2
XFILLER_16_459 VGND VGND VPWR VPWR sky130_fd_sc_hd__decap_3
XFILLER_31_418 VGND VGND VPWR VPWR sky130_fd_sc_hd__decap_3
XFILLER_71_598 VGND VGND VPWR VPWR sky130_fd_sc_hd__decap_3
XFILLER_12_610 VGND VGND VPWR VPWR sky130_fd_sc_hd__decap_3
XFILLER_12_643 VGND VGND VPWR VPWR sky130_fd_sc_hd__fill_1
XFILLER_12_654 VGND VGND VPWR VPWR sky130_fd_sc_hd__decap_3
XFILLER_8_625 VGND VGND VPWR VPWR sky130_fd_sc_hd__decap_3
XFILLER_11_153 VGND VGND VPWR VPWR sky130_fd_sc_hd__decap_3
XFILLER_12_687 VGND VGND VPWR VPWR sky130_fd_sc_hd__decap_3
XFILLER_8_669 VGND VGND VPWR VPWR sky130_fd_sc_hd__decap_3
XFILLER_7_157 VGND VGND VPWR VPWR sky130_fd_sc_hd__fill_1
XTAP_TAPCELL_ROW_59_1031 VGND VPWR sky130_fd_sc_hd__tapvpwrvgnd_1
XFILLER_113_718 VGND VGND VPWR VPWR sky130_fd_sc_hd__decap_3
XFILLER_113_729 VGND VGND VPWR VPWR sky130_fd_sc_hd__decap_3
XFILLER_112_217 VGND VGND VPWR VPWR sky130_fd_sc_hd__fill_1
XFILLER_79_632 VGND VGND VPWR VPWR sky130_fd_sc_hd__decap_3
XFILLER_3_385 VGND VGND VPWR VPWR sky130_fd_sc_hd__decap_3
XFILLER_112_239 VGND VGND VPWR VPWR sky130_fd_sc_hd__decap_3
XFILLER_105_291 VGND VGND VPWR VPWR sky130_fd_sc_hd__fill_2
XFILLER_79_665 VGND VGND VPWR VPWR sky130_fd_sc_hd__decap_3
XFILLER_79_676 VGND VGND VPWR VPWR sky130_fd_sc_hd__decap_3
XFILLER_78_153 VGND VGND VPWR VPWR sky130_fd_sc_hd__fill_2
XFILLER_94_613 VGND VGND VPWR VPWR sky130_fd_sc_hd__decap_3
XFILLER_66_315 VGND VGND VPWR VPWR sky130_fd_sc_hd__decap_3
XFILLER_78_197 VGND VGND VPWR VPWR sky130_fd_sc_hd__decap_3
XFILLER_66_337 VGND VGND VPWR VPWR sky130_fd_sc_hd__decap_3
XFILLER_94_657 VGND VGND VPWR VPWR sky130_fd_sc_hd__decap_3
XFILLER_19_231 VGND VGND VPWR VPWR sky130_fd_sc_hd__fill_1
XFILLER_93_167 VGND VGND VPWR VPWR sky130_fd_sc_hd__fill_1
XFILLER_81_307 VGND VGND VPWR VPWR sky130_fd_sc_hd__decap_3
XFILLER_93_178 VGND VGND VPWR VPWR sky130_fd_sc_hd__decap_3
XFILLER_35_724 VGND VGND VPWR VPWR sky130_fd_sc_hd__decap_3
XFILLER_19_275 VGND VGND VPWR VPWR sky130_fd_sc_hd__decap_3
XFILLER_34_234 VGND VGND VPWR VPWR sky130_fd_sc_hd__decap_3
XFILLER_62_554 VGND VGND VPWR VPWR sky130_fd_sc_hd__decap_3
XFILLER_34_256 VGND VGND VPWR VPWR sky130_fd_sc_hd__decap_3
XFILLER_50_716 VGND VGND VPWR VPWR sky130_fd_sc_hd__decap_3
XFILLER_62_587 VGND VGND VPWR VPWR sky130_fd_sc_hd__fill_1
XTAP_TAPCELL_ROW_17_487 VGND VPWR sky130_fd_sc_hd__tapvpwrvgnd_1
XFILLER_15_481 VGND VGND VPWR VPWR sky130_fd_sc_hd__decap_3
X_4701_ _6989_/Q _6990_/Q _5044_/A VGND VGND VPWR VPWR _5026_/A sky130_fd_sc_hd__and3_2
X_4632_ _4626_/X _4274_/Y _4631_/X VGND VGND VPWR VPWR _4916_/B sky130_fd_sc_hd__a21oi_2
X_4563_ _4563_/A _4577_/B VGND VGND VPWR VPWR _7299_/D sky130_fd_sc_hd__and2_2
X_7351_ _7355_/CLK _7351_/D _6631_/Y VGND VGND VPWR VPWR _7351_/Q sky130_fd_sc_hd__dfrtp_2
XFILLER_116_512 VGND VGND VPWR VPWR sky130_fd_sc_hd__decap_3
Xhold603 _6965_/Q VGND VGND VPWR VPWR _6965_/D sky130_fd_sc_hd__dlygate4sd3_1
X_6302_ _6649_/A VGND VGND VPWR VPWR _6302_/Y sky130_fd_sc_hd__inv_2
Xhold614 _6798_/Q VGND VGND VPWR VPWR _6798_/D sky130_fd_sc_hd__dlygate4sd3_1
XFILLER_7_691 VGND VGND VPWR VPWR sky130_fd_sc_hd__decap_3
Xhold625 _6728_/Q VGND VGND VPWR VPWR _6728_/D sky130_fd_sc_hd__dlygate4sd3_1
X_7282_ _7313_/CLK _7282_/D _6562_/Y VGND VGND VPWR VPWR _7282_/Q sky130_fd_sc_hd__dfrtp_2
XFILLER_116_545 VGND VGND VPWR VPWR sky130_fd_sc_hd__decap_3
Xhold636 _6763_/Q VGND VGND VPWR VPWR _6763_/D sky130_fd_sc_hd__dlygate4sd3_1
Xhold647 _6918_/Q VGND VGND VPWR VPWR _6918_/D sky130_fd_sc_hd__dlygate4sd3_1
XFILLER_104_707 VGND VGND VPWR VPWR sky130_fd_sc_hd__decap_3
Xhold658 _6974_/Q VGND VGND VPWR VPWR _6974_/D sky130_fd_sc_hd__dlygate4sd3_1
XFILLER_116_578 VGND VGND VPWR VPWR sky130_fd_sc_hd__decap_3
Xhold669 _6969_/Q VGND VGND VPWR VPWR _6969_/D sky130_fd_sc_hd__dlygate4sd3_1
XFILLER_116_589 VGND VGND VPWR VPWR sky130_fd_sc_hd__decap_3
X_3376_ _3376_/A _3376_/B VGND VGND VPWR VPWR _3376_/Y sky130_fd_sc_hd__nor2_2
XFILLER_69_131 VGND VGND VPWR VPWR sky130_fd_sc_hd__fill_2
X_5115_ _5101_/A _4292_/C _5113_/Y _5020_/A _5114_/Y VGND VGND VPWR VPWR _5115_/X
+ sky130_fd_sc_hd__o221a_2
XFILLER_69_164 VGND VGND VPWR VPWR sky130_fd_sc_hd__decap_3
XFILLER_111_250 VGND VGND VPWR VPWR sky130_fd_sc_hd__decap_3
XFILLER_84_101 VGND VGND VPWR VPWR sky130_fd_sc_hd__decap_3
XFILLER_69_175 VGND VGND VPWR VPWR sky130_fd_sc_hd__decap_3
XFILLER_85_635 VGND VGND VPWR VPWR sky130_fd_sc_hd__decap_3
XFILLER_57_337 VGND VGND VPWR VPWR sky130_fd_sc_hd__decap_3
X_5046_ _5101_/B VGND VGND VPWR VPWR _5100_/A sky130_fd_sc_hd__inv_2
XFILLER_85_668 VGND VGND VPWR VPWR sky130_fd_sc_hd__decap_3
XFILLER_85_679 VGND VGND VPWR VPWR sky130_fd_sc_hd__decap_3
XFILLER_84_156 VGND VGND VPWR VPWR sky130_fd_sc_hd__decap_3
XFILLER_72_307 VGND VGND VPWR VPWR sky130_fd_sc_hd__fill_1
XFILLER_26_713 VGND VGND VPWR VPWR sky130_fd_sc_hd__decap_3
XFILLER_84_189 VGND VGND VPWR VPWR sky130_fd_sc_hd__decap_3
XFILLER_38_595 VGND VGND VPWR VPWR sky130_fd_sc_hd__decap_3
XTAP_TAPCELL_ROW_36_730 VGND VPWR sky130_fd_sc_hd__tapvpwrvgnd_1
XTAP_TAPCELL_ROW_36_741 VGND VPWR sky130_fd_sc_hd__tapvpwrvgnd_1
X_6997_ _7370_/CLK _6997_/D _6277_/Y VGND VGND VPWR VPWR _6997_/Q sky130_fd_sc_hd__dfrtp_2
XFILLER_25_267 VGND VGND VPWR VPWR sky130_fd_sc_hd__decap_3
XFILLER_41_727 VGND VGND VPWR VPWR sky130_fd_sc_hd__fill_1
XFILLER_40_204 VGND VGND VPWR VPWR sky130_fd_sc_hd__decap_3
XFILLER_40_226 VGND VGND VPWR VPWR sky130_fd_sc_hd__decap_3
XTAP_TAPCELL_ROW_97_1529 VGND VPWR sky130_fd_sc_hd__tapvpwrvgnd_1
XFILLER_5_606 VGND VGND VPWR VPWR sky130_fd_sc_hd__decap_3
XFILLER_5_617 VGND VGND VPWR VPWR sky130_fd_sc_hd__decap_3
XFILLER_107_523 VGND VGND VPWR VPWR sky130_fd_sc_hd__decap_3
XFILLER_107_556 VGND VGND VPWR VPWR sky130_fd_sc_hd__decap_3
XFILLER_107_567 VGND VGND VPWR VPWR sky130_fd_sc_hd__decap_3
XFILLER_108_41 VGND VGND VPWR VPWR sky130_fd_sc_hd__decap_3
XFILLER_122_504 VGND VGND VPWR VPWR sky130_fd_sc_hd__decap_3
XFILLER_68_23 VGND VGND VPWR VPWR sky130_fd_sc_hd__decap_3
XFILLER_108_85 VGND VGND VPWR VPWR sky130_fd_sc_hd__fill_2
XFILLER_122_548 VGND VGND VPWR VPWR sky130_fd_sc_hd__decap_3
XFILLER_68_56 VGND VGND VPWR VPWR sky130_fd_sc_hd__fill_2
XFILLER_76_613 VGND VGND VPWR VPWR sky130_fd_sc_hd__decap_3
XFILLER_102_261 VGND VGND VPWR VPWR sky130_fd_sc_hd__decap_3
XFILLER_0_399 VGND VGND VPWR VPWR sky130_fd_sc_hd__decap_3
XFILLER_76_657 VGND VGND VPWR VPWR sky130_fd_sc_hd__decap_3
XFILLER_48_348 VGND VGND VPWR VPWR sky130_fd_sc_hd__decap_3
XFILLER_75_156 VGND VGND VPWR VPWR sky130_fd_sc_hd__decap_3
XFILLER_75_178 VGND VGND VPWR VPWR sky130_fd_sc_hd__decap_3
XFILLER_91_638 VGND VGND VPWR VPWR sky130_fd_sc_hd__decap_3
XFILLER_63_329 VGND VGND VPWR VPWR sky130_fd_sc_hd__decap_3
XFILLER_17_724 VGND VGND VPWR VPWR sky130_fd_sc_hd__decap_3
Xplace307 _3634_/Y VGND VGND VPWR VPWR _3991_/B sky130_fd_sc_hd__buf_2
XFILLER_84_77 VGND VGND VPWR VPWR sky130_fd_sc_hd__decap_3
XFILLER_29_595 VGND VGND VPWR VPWR sky130_fd_sc_hd__decap_3
Xplace318 _4577_/B VGND VGND VPWR VPWR _4559_/B sky130_fd_sc_hd__buf_2
XFILLER_84_690 VGND VGND VPWR VPWR sky130_fd_sc_hd__decap_3
XFILLER_90_137 VGND VGND VPWR VPWR sky130_fd_sc_hd__decap_3
XTAP_TAPCELL_ROW_106_1647 VGND VPWR sky130_fd_sc_hd__tapvpwrvgnd_1
Xplace329 _4205_/A VGND VGND VPWR VPWR _4432_/B1 sky130_fd_sc_hd__buf_2
XFILLER_17_60 VGND VGND VPWR VPWR sky130_fd_sc_hd__decap_3
XFILLER_17_71 VGND VGND VPWR VPWR sky130_fd_sc_hd__fill_2
XFILLER_44_565 VGND VGND VPWR VPWR sky130_fd_sc_hd__decap_3
XFILLER_16_256 VGND VGND VPWR VPWR sky130_fd_sc_hd__decap_3
XFILLER_32_716 VGND VGND VPWR VPWR sky130_fd_sc_hd__decap_3
XFILLER_16_278 VGND VGND VPWR VPWR sky130_fd_sc_hd__decap_3
XFILLER_71_384 VGND VGND VPWR VPWR sky130_fd_sc_hd__decap_3
XFILLER_31_237 VGND VGND VPWR VPWR sky130_fd_sc_hd__decap_3
XTAP_TAPCELL_ROW_14_446 VGND VPWR sky130_fd_sc_hd__tapvpwrvgnd_1
XFILLER_12_440 VGND VGND VPWR VPWR sky130_fd_sc_hd__decap_3
XFILLER_33_70 VGND VGND VPWR VPWR sky130_fd_sc_hd__fill_2
XFILLER_33_92 VGND VGND VPWR VPWR sky130_fd_sc_hd__decap_3
XFILLER_8_444 VGND VGND VPWR VPWR sky130_fd_sc_hd__decap_3
XFILLER_12_495 VGND VGND VPWR VPWR sky130_fd_sc_hd__fill_2
XFILLER_117_309 VGND VGND VPWR VPWR sky130_fd_sc_hd__fill_2
XFILLER_8_477 VGND VGND VPWR VPWR sky130_fd_sc_hd__decap_3
XTAP_TAPCELL_ROW_117_1787 VGND VPWR sky130_fd_sc_hd__tapvpwrvgnd_1
XFILLER_99_727 VGND VGND VPWR VPWR sky130_fd_sc_hd__fill_1
XFILLER_4_672 VGND VGND VPWR VPWR sky130_fd_sc_hd__decap_3
XFILLER_113_526 VGND VGND VPWR VPWR sky130_fd_sc_hd__decap_3
XFILLER_113_559 VGND VGND VPWR VPWR sky130_fd_sc_hd__fill_1
XFILLER_98_259 VGND VGND VPWR VPWR sky130_fd_sc_hd__fill_1
XFILLER_3_193 VGND VGND VPWR VPWR sky130_fd_sc_hd__decap_3
XFILLER_100_209 VGND VGND VPWR VPWR sky130_fd_sc_hd__decap_3
XFILLER_79_473 VGND VGND VPWR VPWR sky130_fd_sc_hd__decap_3
XFILLER_39_304 VGND VGND VPWR VPWR sky130_fd_sc_hd__decap_3
XFILLER_121_570 VGND VGND VPWR VPWR sky130_fd_sc_hd__decap_3
XFILLER_67_635 VGND VGND VPWR VPWR sky130_fd_sc_hd__decap_3
XFILLER_94_421 VGND VGND VPWR VPWR sky130_fd_sc_hd__decap_3
XFILLER_39_337 VGND VGND VPWR VPWR sky130_fd_sc_hd__decap_3
XFILLER_67_668 VGND VGND VPWR VPWR sky130_fd_sc_hd__decap_3
XFILLER_12_3 VGND VGND VPWR VPWR sky130_fd_sc_hd__decap_3
XFILLER_67_679 VGND VGND VPWR VPWR sky130_fd_sc_hd__decap_3
XFILLER_82_616 VGND VGND VPWR VPWR sky130_fd_sc_hd__decap_3
XFILLER_81_104 VGND VGND VPWR VPWR sky130_fd_sc_hd__decap_3
XFILLER_54_318 VGND VGND VPWR VPWR sky130_fd_sc_hd__decap_3
X_6920_ _7215_/CLK _6920_/D VGND VGND VPWR VPWR _6920_/Q sky130_fd_sc_hd__dfxtp_2
X_6851_ clkload5/A _6851_/D VGND VGND VPWR VPWR _6851_/Q sky130_fd_sc_hd__dfxtp_2
XFILLER_62_340 VGND VGND VPWR VPWR sky130_fd_sc_hd__decap_3
XFILLER_90_660 VGND VGND VPWR VPWR sky130_fd_sc_hd__decap_3
XTAP_TAPCELL_ROW_33_700 VGND VPWR sky130_fd_sc_hd__tapvpwrvgnd_1
XTAP_TAPCELL_ROW_81_1319 VGND VPWR sky130_fd_sc_hd__tapvpwrvgnd_1
XFILLER_23_727 VGND VGND VPWR VPWR sky130_fd_sc_hd__fill_1
XFILLER_22_204 VGND VGND VPWR VPWR sky130_fd_sc_hd__decap_3
XFILLER_62_373 VGND VGND VPWR VPWR sky130_fd_sc_hd__decap_3
Xfanout19 _6664_/A VGND VGND VPWR VPWR _6658_/A sky130_fd_sc_hd__clkbuf_2
XFILLER_90_693 VGND VGND VPWR VPWR sky130_fd_sc_hd__decap_3
X_3994_ _7345_/Q _3993_/X _3996_/S VGND VGND VPWR VPWR _7345_/D sky130_fd_sc_hd__mux2_2
X_6782_ _7386_/CLK _6782_/D VGND VGND VPWR VPWR _6782_/Q sky130_fd_sc_hd__dfxtp_2
XFILLER_50_557 VGND VGND VPWR VPWR sky130_fd_sc_hd__fill_2
XFILLER_22_259 VGND VGND VPWR VPWR sky130_fd_sc_hd__decap_3
X_5733_ _7372_/Q _5733_/A1 _5735_/S VGND VGND VPWR VPWR _6716_/D sky130_fd_sc_hd__mux2_2
X_5664_ _5664_/A _5664_/B _5664_/C _5664_/D VGND VGND VPWR VPWR _5665_/D sky130_fd_sc_hd__and4_2
X_7403_ _7403_/CLK _7403_/D _6683_/Y VGND VGND VPWR VPWR _7403_/Q sky130_fd_sc_hd__dfrtp_2
X_4615_ _4282_/Y _4612_/B _3610_/A VGND VGND VPWR VPWR _4615_/Y sky130_fd_sc_hd__a21oi_2
X_5595_ _5595_/A _5595_/B VGND VGND VPWR VPWR _7030_/D sky130_fd_sc_hd__or2_2
XFILLER_116_320 VGND VGND VPWR VPWR sky130_fd_sc_hd__fill_2
X_4546_ _4546_/A _4559_/B VGND VGND VPWR VPWR _7307_/D sky130_fd_sc_hd__and2_2
X_7334_ _7368_/CLK _7334_/D _6614_/Y VGND VGND VPWR VPWR _7334_/Q sky130_fd_sc_hd__dfrtp_2
XFILLER_89_204 VGND VGND VPWR VPWR sky130_fd_sc_hd__decap_3
X_7265_ _7395_/CLK _7265_/D _6545_/Y VGND VGND VPWR VPWR _7265_/Q sky130_fd_sc_hd__dfrtp_2
XTAP_TAPCELL_ROW_92_1459 VGND VPWR sky130_fd_sc_hd__tapvpwrvgnd_1
XFILLER_89_237 VGND VGND VPWR VPWR sky130_fd_sc_hd__decap_3
XFILLER_104_548 VGND VGND VPWR VPWR sky130_fd_sc_hd__decap_3
X_7196_ _7392_/CLK _7196_/D _6476_/Y VGND VGND VPWR VPWR _7196_/Q sky130_fd_sc_hd__dfrtp_2
XFILLER_58_602 VGND VGND VPWR VPWR sky130_fd_sc_hd__decap_3
XFILLER_100_710 VGND VGND VPWR VPWR sky130_fd_sc_hd__decap_3
X_3359_ _6983_/Q _5130_/A VGND VGND VPWR VPWR _3376_/A sky130_fd_sc_hd__or2_2
Xhold1100 _7169_/Q VGND VGND VPWR VPWR _5323_/A0 sky130_fd_sc_hd__dlygate4sd3_1
XFILLER_97_281 VGND VGND VPWR VPWR sky130_fd_sc_hd__decap_3
XFILLER_58_635 VGND VGND VPWR VPWR sky130_fd_sc_hd__decap_3
XFILLER_112_581 VGND VGND VPWR VPWR sky130_fd_sc_hd__decap_3
Xhold1111 _7285_/Q VGND VGND VPWR VPWR _4591_/A sky130_fd_sc_hd__dlygate4sd3_1
XFILLER_112_592 VGND VGND VPWR VPWR sky130_fd_sc_hd__decap_3
Xhold1122 _7225_/Q VGND VGND VPWR VPWR _5207_/A sky130_fd_sc_hd__dlygate4sd3_1
XFILLER_58_657 VGND VGND VPWR VPWR sky130_fd_sc_hd__decap_3
XFILLER_57_134 VGND VGND VPWR VPWR sky130_fd_sc_hd__decap_3
Xhold1133 _7149_/Q VGND VGND VPWR VPWR _5367_/A0 sky130_fd_sc_hd__dlygate4sd3_1
Xhold1144 _7131_/Q VGND VGND VPWR VPWR _5404_/A0 sky130_fd_sc_hd__dlygate4sd3_1
Xhold1155 _7124_/Q VGND VGND VPWR VPWR _5419_/A0 sky130_fd_sc_hd__dlygate4sd3_1
XFILLER_85_465 VGND VGND VPWR VPWR sky130_fd_sc_hd__decap_3
XFILLER_73_605 VGND VGND VPWR VPWR sky130_fd_sc_hd__decap_3
XFILLER_57_167 VGND VGND VPWR VPWR sky130_fd_sc_hd__fill_1
Xhold1166 _7269_/Q VGND VGND VPWR VPWR _4879_/A0 sky130_fd_sc_hd__dlygate4sd3_1
Xhold1177 _7154_/Q VGND VGND VPWR VPWR _5354_/A0 sky130_fd_sc_hd__dlygate4sd3_1
XFILLER_73_638 VGND VGND VPWR VPWR sky130_fd_sc_hd__decap_3
Xhold1188 _7376_/Q VGND VGND VPWR VPWR _3924_/A1 sky130_fd_sc_hd__dlygate4sd3_1
XFILLER_72_115 VGND VGND VPWR VPWR sky130_fd_sc_hd__decap_3
Xhold1199 _7123_/Q VGND VGND VPWR VPWR _5421_/A0 sky130_fd_sc_hd__dlygate4sd3_1
XFILLER_66_690 VGND VGND VPWR VPWR sky130_fd_sc_hd__decap_3
XFILLER_53_351 VGND VGND VPWR VPWR sky130_fd_sc_hd__decap_3
XFILLER_14_716 VGND VGND VPWR VPWR sky130_fd_sc_hd__decap_3
XFILLER_81_671 VGND VGND VPWR VPWR sky130_fd_sc_hd__fill_1
XFILLER_81_682 VGND VGND VPWR VPWR sky130_fd_sc_hd__decap_3
XFILLER_26_598 VGND VGND VPWR VPWR sky130_fd_sc_hd__decap_3
XFILLER_13_237 VGND VGND VPWR VPWR sky130_fd_sc_hd__decap_3
XFILLER_80_192 VGND VGND VPWR VPWR sky130_fd_sc_hd__decap_3
XFILLER_110_53 VGND VGND VPWR VPWR sky130_fd_sc_hd__decap_3
XFILLER_9_219 VGND VGND VPWR VPWR sky130_fd_sc_hd__decap_3
XFILLER_70_24 VGND VGND VPWR VPWR sky130_fd_sc_hd__decap_3
XTAP_TAPCELL_ROW_11_405 VGND VPWR sky130_fd_sc_hd__tapvpwrvgnd_1
XFILLER_70_35 VGND VGND VPWR VPWR sky130_fd_sc_hd__decap_3
XTAP_TAPCELL_ROW_101_1577 VGND VPWR sky130_fd_sc_hd__tapvpwrvgnd_1
XTAP_TAPCELL_ROW_11_416 VGND VPWR sky130_fd_sc_hd__tapvpwrvgnd_1
XFILLER_21_270 VGND VGND VPWR VPWR sky130_fd_sc_hd__decap_3
XFILLER_21_281 VGND VGND VPWR VPWR sky130_fd_sc_hd__decap_3
XFILLER_119_51 VGND VGND VPWR VPWR sky130_fd_sc_hd__decap_3
XTAP_TAPCELL_ROW_56_1001 VGND VPWR sky130_fd_sc_hd__tapvpwrvgnd_1
XFILLER_79_33 VGND VGND VPWR VPWR sky130_fd_sc_hd__decap_3
XFILLER_119_84 VGND VGND VPWR VPWR sky130_fd_sc_hd__decap_3
XFILLER_107_342 VGND VGND VPWR VPWR sky130_fd_sc_hd__fill_2
XFILLER_107_353 VGND VGND VPWR VPWR sky130_fd_sc_hd__decap_3
XFILLER_79_66 VGND VGND VPWR VPWR sky130_fd_sc_hd__decap_3
XFILLER_1_620 VGND VGND VPWR VPWR sky130_fd_sc_hd__decap_3
XFILLER_122_323 VGND VGND VPWR VPWR sky130_fd_sc_hd__decap_3
XFILLER_96_719 VGND VGND VPWR VPWR sky130_fd_sc_hd__decap_3
XFILLER_1_653 VGND VGND VPWR VPWR sky130_fd_sc_hd__decap_3
XFILLER_0_141 VGND VGND VPWR VPWR sky130_fd_sc_hd__decap_3
XFILLER_110_518 VGND VGND VPWR VPWR sky130_fd_sc_hd__decap_3
XFILLER_76_410 VGND VGND VPWR VPWR sky130_fd_sc_hd__decap_3
XFILLER_103_570 VGND VGND VPWR VPWR sky130_fd_sc_hd__decap_3
XFILLER_76_421 VGND VGND VPWR VPWR sky130_fd_sc_hd__decap_3
XFILLER_49_635 VGND VGND VPWR VPWR sky130_fd_sc_hd__decap_3
XFILLER_1_697 VGND VGND VPWR VPWR sky130_fd_sc_hd__decap_3
XFILLER_49_668 VGND VGND VPWR VPWR sky130_fd_sc_hd__decap_3
XFILLER_49_679 VGND VGND VPWR VPWR sky130_fd_sc_hd__decap_3
XFILLER_64_616 VGND VGND VPWR VPWR sky130_fd_sc_hd__decap_3
XFILLER_36_318 VGND VGND VPWR VPWR sky130_fd_sc_hd__decap_3
XTAP_TAPCELL_ROW_19_516 VGND VPWR sky130_fd_sc_hd__tapvpwrvgnd_1
XFILLER_91_413 VGND VGND VPWR VPWR sky130_fd_sc_hd__decap_3
XFILLER_48_189 VGND VGND VPWR VPWR sky130_fd_sc_hd__fill_2
XFILLER_91_435 VGND VGND VPWR VPWR sky130_fd_sc_hd__decap_3
XTAP_TAPCELL_ROW_67_1141 VGND VPWR sky130_fd_sc_hd__tapvpwrvgnd_1
XFILLER_44_340 VGND VGND VPWR VPWR sky130_fd_sc_hd__decap_3
XFILLER_72_660 VGND VGND VPWR VPWR sky130_fd_sc_hd__decap_3
XFILLER_44_351 VGND VGND VPWR VPWR sky130_fd_sc_hd__decap_3
XFILLER_17_576 VGND VGND VPWR VPWR sky130_fd_sc_hd__decap_3
XFILLER_32_513 VGND VGND VPWR VPWR sky130_fd_sc_hd__fill_2
XFILLER_72_693 VGND VGND VPWR VPWR sky130_fd_sc_hd__decap_3
XFILLER_71_192 VGND VGND VPWR VPWR sky130_fd_sc_hd__decap_3
XFILLER_20_719 VGND VGND VPWR VPWR sky130_fd_sc_hd__decap_3
XFILLER_81_6 VGND VGND VPWR VPWR sky130_fd_sc_hd__decap_3
XTAP_TAPCELL_ROW_119_1816 VGND VPWR sky130_fd_sc_hd__tapvpwrvgnd_1
XFILLER_118_607 VGND VGND VPWR VPWR sky130_fd_sc_hd__decap_3
XFILLER_8_274 VGND VGND VPWR VPWR sky130_fd_sc_hd__decap_3
X_4400_ _7178_/Q _4430_/B1 _4428_/B1 _7146_/Q _4399_/X VGND VGND VPWR VPWR _4400_/X
+ sky130_fd_sc_hd__a221o_2
Xoutput505 _3449_/C VGND VGND VPWR VPWR instruction_out[23] sky130_fd_sc_hd__clkdlybuf4s25_1
Xoutput516 _3339_/C1 VGND VGND VPWR VPWR instruction_out[6] sky130_fd_sc_hd__clkdlybuf4s25_1
XTAP_TAPCELL_ROW_78_1281 VGND VPWR sky130_fd_sc_hd__tapvpwrvgnd_1
Xoutput527 _6993_/Q VGND VGND VPWR VPWR pc_out[16] sky130_fd_sc_hd__clkdlybuf4s25_1
X_4331_ _7223_/Q _4353_/A2 _4534_/S _7036_/Q VGND VGND VPWR VPWR _4331_/X sky130_fd_sc_hd__a22o_2
Xoutput538 _7003_/Q VGND VGND VPWR VPWR pc_out[26] sky130_fd_sc_hd__clkdlybuf4s25_1
XFILLER_5_52 VGND VGND VPWR VPWR sky130_fd_sc_hd__decap_3
Xoutput549 _6984_/Q VGND VGND VPWR VPWR pc_out[7] sky130_fd_sc_hd__clkdlybuf4s25_1
X_7050_ _7395_/CLK _7050_/D _6330_/Y VGND VGND VPWR VPWR _7050_/Q sky130_fd_sc_hd__dfrtp_2
X_4262_ _7230_/Q _4349_/B1 _4534_/S _7294_/Q VGND VGND VPWR VPWR _4262_/X sky130_fd_sc_hd__a22o_2
XFILLER_99_579 VGND VGND VPWR VPWR sky130_fd_sc_hd__decap_3
XFILLER_86_218 VGND VGND VPWR VPWR sky130_fd_sc_hd__decap_3
X_4193_ _7359_/Q _4270_/B _4351_/A2 _7103_/Q VGND VGND VPWR VPWR _4193_/X sky130_fd_sc_hd__a22o_2
XFILLER_94_262 VGND VGND VPWR VPWR sky130_fd_sc_hd__decap_3
XFILLER_67_476 VGND VGND VPWR VPWR sky130_fd_sc_hd__decap_3
XFILLER_39_178 VGND VGND VPWR VPWR sky130_fd_sc_hd__decap_3
XFILLER_55_638 VGND VGND VPWR VPWR sky130_fd_sc_hd__decap_3
XFILLER_48_690 VGND VGND VPWR VPWR sky130_fd_sc_hd__decap_3
X_6903_ clkload8/A _6903_/D VGND VGND VPWR VPWR _6903_/Q sky130_fd_sc_hd__dfxtp_2
XFILLER_70_619 VGND VGND VPWR VPWR sky130_fd_sc_hd__decap_3
XFILLER_63_671 VGND VGND VPWR VPWR sky130_fd_sc_hd__fill_1
XFILLER_23_502 VGND VGND VPWR VPWR sky130_fd_sc_hd__fill_2
XFILLER_63_682 VGND VGND VPWR VPWR sky130_fd_sc_hd__decap_3
X_6834_ _7215_/CLK _6834_/D VGND VGND VPWR VPWR _6834_/Q sky130_fd_sc_hd__dfxtp_2
XFILLER_35_384 VGND VGND VPWR VPWR sky130_fd_sc_hd__decap_3
XFILLER_50_321 VGND VGND VPWR VPWR sky130_fd_sc_hd__decap_3
XFILLER_23_568 VGND VGND VPWR VPWR sky130_fd_sc_hd__decap_3
X_6765_ _6978_/CLK _6765_/D VGND VGND VPWR VPWR _6765_/Q sky130_fd_sc_hd__dfxtp_2
XFILLER_50_365 VGND VGND VPWR VPWR sky130_fd_sc_hd__fill_1
X_3977_ _7352_/Q hold978/X _3977_/S VGND VGND VPWR VPWR _7352_/D sky130_fd_sc_hd__mux2_2
X_6696_ _7345_/CLK _6696_/D VGND VGND VPWR VPWR _6696_/Q sky130_fd_sc_hd__dfxtp_2
XFILLER_109_629 VGND VGND VPWR VPWR sky130_fd_sc_hd__decap_3
X_5647_ _5647_/A _5647_/B VGND VGND VPWR VPWR _5647_/Y sky130_fd_sc_hd__nand2_2
XFILLER_108_128 VGND VGND VPWR VPWR sky130_fd_sc_hd__fill_2
XFILLER_40_49 VGND VGND VPWR VPWR sky130_fd_sc_hd__decap_3
XFILLER_117_662 VGND VGND VPWR VPWR sky130_fd_sc_hd__decap_3
XFILLER_117_673 VGND VGND VPWR VPWR sky130_fd_sc_hd__decap_3
X_7317_ _7318_/CLK _7317_/D _6597_/Y VGND VGND VPWR VPWR _7317_/Q sky130_fd_sc_hd__dfrtp_2
X_7248_ _7345_/CLK _7248_/D _6528_/Y VGND VGND VPWR VPWR _7248_/Q sky130_fd_sc_hd__dfrtp_2
XFILLER_78_719 VGND VGND VPWR VPWR sky130_fd_sc_hd__decap_3
XFILLER_104_389 VGND VGND VPWR VPWR sky130_fd_sc_hd__decap_3
XFILLER_58_410 VGND VGND VPWR VPWR sky130_fd_sc_hd__decap_3
X_7179_ _7399_/CLK _7179_/D _6459_/Y VGND VGND VPWR VPWR _7179_/Q sky130_fd_sc_hd__dfrtp_2
XFILLER_58_421 VGND VGND VPWR VPWR sky130_fd_sc_hd__decap_3
XFILLER_105_53 VGND VGND VPWR VPWR sky130_fd_sc_hd__decap_3
XFILLER_58_465 VGND VGND VPWR VPWR sky130_fd_sc_hd__decap_3
XFILLER_46_605 VGND VGND VPWR VPWR sky130_fd_sc_hd__decap_3
XFILLER_85_262 VGND VGND VPWR VPWR sky130_fd_sc_hd__decap_3
XFILLER_100_562 VGND VGND VPWR VPWR sky130_fd_sc_hd__decap_3
XFILLER_46_638 VGND VGND VPWR VPWR sky130_fd_sc_hd__decap_3
XFILLER_85_284 VGND VGND VPWR VPWR sky130_fd_sc_hd__decap_3
XFILLER_100_595 VGND VGND VPWR VPWR sky130_fd_sc_hd__decap_3
XFILLER_65_57 VGND VGND VPWR VPWR sky130_fd_sc_hd__decap_3
XFILLER_73_446 VGND VGND VPWR VPWR sky130_fd_sc_hd__fill_2
XFILLER_61_608 VGND VGND VPWR VPWR sky130_fd_sc_hd__decap_3
XFILLER_73_479 VGND VGND VPWR VPWR sky130_fd_sc_hd__decap_3
XFILLER_54_660 VGND VGND VPWR VPWR sky130_fd_sc_hd__decap_3
XFILLER_26_351 VGND VGND VPWR VPWR sky130_fd_sc_hd__decap_3
XFILLER_121_30 VGND VGND VPWR VPWR sky130_fd_sc_hd__decap_3
XTAP_TAPCELL_ROW_103_1606 VGND VPWR sky130_fd_sc_hd__tapvpwrvgnd_1
XTAP_TAPCELL_ROW_44_839 VGND VPWR sky130_fd_sc_hd__tapvpwrvgnd_1
XFILLER_81_12 VGND VGND VPWR VPWR sky130_fd_sc_hd__decap_3
XFILLER_54_693 VGND VGND VPWR VPWR sky130_fd_sc_hd__decap_3
XFILLER_121_63 VGND VGND VPWR VPWR sky130_fd_sc_hd__decap_3
XFILLER_41_321 VGND VGND VPWR VPWR sky130_fd_sc_hd__fill_2
XFILLER_14_546 VGND VGND VPWR VPWR sky130_fd_sc_hd__decap_3
XFILLER_121_96 VGND VGND VPWR VPWR sky130_fd_sc_hd__decap_3
XFILLER_41_343 VGND VGND VPWR VPWR sky130_fd_sc_hd__decap_3
XFILLER_14_579 VGND VGND VPWR VPWR sky130_fd_sc_hd__decap_3
XTAP_TAPCELL_ROW_24_574 VGND VPWR sky130_fd_sc_hd__tapvpwrvgnd_1
XTAP_TAPCELL_ROW_24_585 VGND VPWR sky130_fd_sc_hd__tapvpwrvgnd_1
XTAP_TAPCELL_ROW_62_1071 VGND VPWR sky130_fd_sc_hd__tapvpwrvgnd_1
XFILLER_14_72 VGND VGND VPWR VPWR sky130_fd_sc_hd__decap_3
XFILLER_14_83 VGND VGND VPWR VPWR sky130_fd_sc_hd__fill_1
XFILLER_6_701 VGND VGND VPWR VPWR sky130_fd_sc_hd__decap_3
XFILLER_14_94 VGND VGND VPWR VPWR sky130_fd_sc_hd__decap_3
XFILLER_6_734 VGND VGND VPWR VPWR sky130_fd_sc_hd__fill_1
XFILLER_5_222 VGND VGND VPWR VPWR sky130_fd_sc_hd__fill_2
XFILLER_108_640 VGND VGND VPWR VPWR sky130_fd_sc_hd__decap_3
XFILLER_108_651 VGND VGND VPWR VPWR sky130_fd_sc_hd__decap_3
XFILLER_108_684 VGND VGND VPWR VPWR sky130_fd_sc_hd__decap_3
XFILLER_107_161 VGND VGND VPWR VPWR sky130_fd_sc_hd__decap_3
XTAP_TAPCELL_ROW_114_1746 VGND VPWR sky130_fd_sc_hd__tapvpwrvgnd_1
XFILLER_107_172 VGND VGND VPWR VPWR sky130_fd_sc_hd__decap_3
XFILLER_5_299 VGND VGND VPWR VPWR sky130_fd_sc_hd__decap_3
XFILLER_123_632 VGND VGND VPWR VPWR sky130_fd_sc_hd__decap_3
XFILLER_123_665 VGND VGND VPWR VPWR sky130_fd_sc_hd__decap_3
XFILLER_123_687 VGND VGND VPWR VPWR sky130_fd_sc_hd__decap_3
XFILLER_1_483 VGND VGND VPWR VPWR sky130_fd_sc_hd__decap_3
XFILLER_122_197 VGND VGND VPWR VPWR sky130_fd_sc_hd__decap_3
XFILLER_110_359 VGND VGND VPWR VPWR sky130_fd_sc_hd__decap_3
XFILLER_76_240 VGND VGND VPWR VPWR sky130_fd_sc_hd__decap_3
XFILLER_76_262 VGND VGND VPWR VPWR sky130_fd_sc_hd__decap_3
XFILLER_92_722 VGND VGND VPWR VPWR sky130_fd_sc_hd__decap_3
XFILLER_64_413 VGND VGND VPWR VPWR sky130_fd_sc_hd__decap_3
XFILLER_91_210 VGND VGND VPWR VPWR sky130_fd_sc_hd__decap_3
XFILLER_37_638 VGND VGND VPWR VPWR sky130_fd_sc_hd__decap_3
XFILLER_91_243 VGND VGND VPWR VPWR sky130_fd_sc_hd__decap_3
XFILLER_52_619 VGND VGND VPWR VPWR sky130_fd_sc_hd__decap_3
XFILLER_45_671 VGND VGND VPWR VPWR sky130_fd_sc_hd__fill_1
XFILLER_91_287 VGND VGND VPWR VPWR sky130_fd_sc_hd__decap_3
XFILLER_45_682 VGND VGND VPWR VPWR sky130_fd_sc_hd__decap_3
X_3900_ _3898_/X _3899_/X _5151_/A VGND VGND VPWR VPWR _3900_/Y sky130_fd_sc_hd__o21ai_2
XFILLER_32_321 VGND VGND VPWR VPWR sky130_fd_sc_hd__decap_3
XFILLER_60_663 VGND VGND VPWR VPWR sky130_fd_sc_hd__decap_3
XFILLER_32_354 VGND VGND VPWR VPWR sky130_fd_sc_hd__decap_3
X_3831_ _3923_/A1 _3828_/X _3830_/X _3714_/X VGND VGND VPWR VPWR _3831_/X sky130_fd_sc_hd__a22o_2
XFILLER_20_505 VGND VGND VPWR VPWR sky130_fd_sc_hd__decap_3
XFILLER_32_365 VGND VGND VPWR VPWR sky130_fd_sc_hd__decap_3
XFILLER_60_696 VGND VGND VPWR VPWR sky130_fd_sc_hd__decap_3
X_3762_ _3746_/C _3759_/X _3760_/X _4799_/A VGND VGND VPWR VPWR _3762_/X sky130_fd_sc_hd__o31a_2
X_6550_ _6650_/A VGND VGND VPWR VPWR _6550_/Y sky130_fd_sc_hd__inv_2
XFILLER_9_550 VGND VGND VPWR VPWR sky130_fd_sc_hd__decap_3
XFILLER_9_561 VGND VGND VPWR VPWR sky130_fd_sc_hd__decap_3
X_3693_ _3693_/A0 _3692_/X _4799_/A VGND VGND VPWR VPWR _7403_/D sky130_fd_sc_hd__mux2_2
X_6481_ _6642_/A VGND VGND VPWR VPWR _6481_/Y sky130_fd_sc_hd__inv_2
XFILLER_9_594 VGND VGND VPWR VPWR sky130_fd_sc_hd__decap_3
XFILLER_114_610 VGND VGND VPWR VPWR sky130_fd_sc_hd__decap_3
XFILLER_114_643 VGND VGND VPWR VPWR sky130_fd_sc_hd__fill_1
X_7102_ _7356_/CLK _7102_/D _6382_/Y VGND VGND VPWR VPWR _7102_/Q sky130_fd_sc_hd__dfrtp_2
XFILLER_99_343 VGND VGND VPWR VPWR sky130_fd_sc_hd__decap_3
X_4314_ _4376_/A _4364_/A _4364_/B _4313_/D VGND VGND VPWR VPWR _4315_/B sky130_fd_sc_hd__o31ai_2
XFILLER_114_654 VGND VGND VPWR VPWR sky130_fd_sc_hd__decap_3
X_5294_ _5294_/A _5294_/B VGND VGND VPWR VPWR _5294_/Y sky130_fd_sc_hd__nor2_2
XFILLER_87_505 VGND VGND VPWR VPWR sky130_fd_sc_hd__decap_3
XFILLER_59_207 VGND VGND VPWR VPWR sky130_fd_sc_hd__decap_3
XFILLER_113_153 VGND VGND VPWR VPWR sky130_fd_sc_hd__decap_3
XFILLER_114_687 VGND VGND VPWR VPWR sky130_fd_sc_hd__decap_3
X_4245_ _7357_/Q _4261_/A2 _4348_/A2 _7165_/Q _4244_/X VGND VGND VPWR VPWR _4248_/B
+ sky130_fd_sc_hd__a221o_2
X_7033_ _7345_/CLK _7033_/D _6313_/Y VGND VGND VPWR VPWR _7033_/Q sky130_fd_sc_hd__dfrtp_2
XFILLER_101_326 VGND VGND VPWR VPWR sky130_fd_sc_hd__fill_2
XFILLER_101_348 VGND VGND VPWR VPWR sky130_fd_sc_hd__decap_3
XFILLER_101_359 VGND VGND VPWR VPWR sky130_fd_sc_hd__fill_2
X_4176_ _7168_/Q _4459_/C1 _4348_/B1 _7136_/Q VGND VGND VPWR VPWR _4176_/X sky130_fd_sc_hd__a22o_2
XFILLER_83_700 VGND VGND VPWR VPWR sky130_fd_sc_hd__decap_3
XFILLER_28_616 VGND VGND VPWR VPWR sky130_fd_sc_hd__decap_3
XFILLER_55_402 VGND VGND VPWR VPWR sky130_fd_sc_hd__decap_3
XFILLER_95_582 VGND VGND VPWR VPWR sky130_fd_sc_hd__decap_3
XFILLER_67_284 VGND VGND VPWR VPWR sky130_fd_sc_hd__decap_3
XFILLER_82_243 VGND VGND VPWR VPWR sky130_fd_sc_hd__fill_1
XFILLER_43_608 VGND VGND VPWR VPWR sky130_fd_sc_hd__decap_3
XFILLER_82_265 VGND VGND VPWR VPWR sky130_fd_sc_hd__decap_3
XFILLER_36_660 VGND VGND VPWR VPWR sky130_fd_sc_hd__decap_3
XFILLER_70_416 VGND VGND VPWR VPWR sky130_fd_sc_hd__decap_3
XFILLER_42_107 VGND VGND VPWR VPWR sky130_fd_sc_hd__decap_3
XFILLER_36_693 VGND VGND VPWR VPWR sky130_fd_sc_hd__decap_3
XFILLER_35_181 VGND VGND VPWR VPWR sky130_fd_sc_hd__fill_1
XFILLER_51_641 VGND VGND VPWR VPWR sky130_fd_sc_hd__decap_3
XFILLER_35_192 VGND VGND VPWR VPWR sky130_fd_sc_hd__decap_3
XFILLER_23_332 VGND VGND VPWR VPWR sky130_fd_sc_hd__decap_3
XFILLER_23_343 VGND VGND VPWR VPWR sky130_fd_sc_hd__decap_3
X_6817_ _6967_/CLK _6817_/D VGND VGND VPWR VPWR _6817_/Q sky130_fd_sc_hd__dfxtp_2
XFILLER_51_685 VGND VGND VPWR VPWR sky130_fd_sc_hd__decap_3
XFILLER_23_387 VGND VGND VPWR VPWR sky130_fd_sc_hd__decap_3
XFILLER_11_538 VGND VGND VPWR VPWR sky130_fd_sc_hd__decap_3
XFILLER_50_184 VGND VGND VPWR VPWR sky130_fd_sc_hd__decap_3
X_6748_ clkload7/A _6748_/D VGND VGND VPWR VPWR _6748_/Q sky130_fd_sc_hd__dfxtp_2
XTAP_TAPCELL_ROW_21_544 VGND VPWR sky130_fd_sc_hd__tapvpwrvgnd_1
XFILLER_109_426 VGND VGND VPWR VPWR sky130_fd_sc_hd__decap_3
X_6679_ _6684_/A VGND VGND VPWR VPWR _6679_/Y sky130_fd_sc_hd__inv_2
XFILLER_3_715 VGND VGND VPWR VPWR sky130_fd_sc_hd__decap_3
XFILLER_2_203 VGND VGND VPWR VPWR sky130_fd_sc_hd__decap_3
XFILLER_117_470 VGND VGND VPWR VPWR sky130_fd_sc_hd__decap_3
XFILLER_105_632 VGND VGND VPWR VPWR sky130_fd_sc_hd__decap_3
XFILLER_2_236 VGND VGND VPWR VPWR sky130_fd_sc_hd__fill_2
XFILLER_104_131 VGND VGND VPWR VPWR sky130_fd_sc_hd__decap_3
XFILLER_2_258 VGND VGND VPWR VPWR sky130_fd_sc_hd__fill_2
XFILLER_105_665 VGND VGND VPWR VPWR sky130_fd_sc_hd__decap_3
XFILLER_105_676 VGND VGND VPWR VPWR sky130_fd_sc_hd__decap_3
XFILLER_78_516 VGND VGND VPWR VPWR sky130_fd_sc_hd__decap_3
XFILLER_104_153 VGND VGND VPWR VPWR sky130_fd_sc_hd__decap_3
XFILLER_120_613 VGND VGND VPWR VPWR sky130_fd_sc_hd__decap_3
XFILLER_116_41 VGND VGND VPWR VPWR sky130_fd_sc_hd__decap_3
XFILLER_76_23 VGND VGND VPWR VPWR sky130_fd_sc_hd__decap_3
XFILLER_116_74 VGND VGND VPWR VPWR sky130_fd_sc_hd__decap_3
XFILLER_116_85 VGND VGND VPWR VPWR sky130_fd_sc_hd__decap_3
XFILLER_120_657 VGND VGND VPWR VPWR sky130_fd_sc_hd__decap_3
XTAP_TAPCELL_ROW_49_909 VGND VPWR sky130_fd_sc_hd__tapvpwrvgnd_1
XFILLER_86_571 VGND VGND VPWR VPWR sky130_fd_sc_hd__decap_3
XFILLER_74_722 VGND VGND VPWR VPWR sky130_fd_sc_hd__decap_3
XFILLER_58_273 VGND VGND VPWR VPWR sky130_fd_sc_hd__decap_3
XFILLER_19_638 VGND VGND VPWR VPWR sky130_fd_sc_hd__decap_3
XFILLER_46_424 VGND VGND VPWR VPWR sky130_fd_sc_hd__decap_3
XFILLER_18_115 VGND VGND VPWR VPWR sky130_fd_sc_hd__decap_3
XFILLER_73_221 VGND VGND VPWR VPWR sky130_fd_sc_hd__decap_3
XFILLER_58_295 VGND VGND VPWR VPWR sky130_fd_sc_hd__decap_3
XTAP_TAPCELL_ROW_29_644 VGND VPWR sky130_fd_sc_hd__tapvpwrvgnd_1
XFILLER_73_243 VGND VGND VPWR VPWR sky130_fd_sc_hd__decap_3
XFILLER_34_619 VGND VGND VPWR VPWR sky130_fd_sc_hd__decap_3
XFILLER_27_671 VGND VGND VPWR VPWR sky130_fd_sc_hd__fill_1
XTAP_TAPCELL_ROW_64_1100 VGND VPWR sky130_fd_sc_hd__tapvpwrvgnd_1
XFILLER_73_287 VGND VGND VPWR VPWR sky130_fd_sc_hd__decap_3
XFILLER_61_427 VGND VGND VPWR VPWR sky130_fd_sc_hd__decap_3
XTAP_TAPCELL_ROW_1_280 VGND VPWR sky130_fd_sc_hd__tapvpwrvgnd_1
XFILLER_27_682 VGND VGND VPWR VPWR sky130_fd_sc_hd__decap_3
XFILLER_61_449 VGND VGND VPWR VPWR sky130_fd_sc_hd__decap_3
XFILLER_92_88 VGND VGND VPWR VPWR sky130_fd_sc_hd__decap_3
XFILLER_54_490 VGND VGND VPWR VPWR sky130_fd_sc_hd__decap_3
XFILLER_42_663 VGND VGND VPWR VPWR sky130_fd_sc_hd__decap_3
XFILLER_14_365 VGND VGND VPWR VPWR sky130_fd_sc_hd__decap_3
XFILLER_41_151 VGND VGND VPWR VPWR sky130_fd_sc_hd__decap_3
XFILLER_42_696 VGND VGND VPWR VPWR sky130_fd_sc_hd__decap_3
XFILLER_10_560 VGND VGND VPWR VPWR sky130_fd_sc_hd__decap_3
XFILLER_6_542 VGND VGND VPWR VPWR sky130_fd_sc_hd__decap_3
XFILLER_115_418 VGND VGND VPWR VPWR sky130_fd_sc_hd__decap_3
XFILLER_6_575 VGND VGND VPWR VPWR sky130_fd_sc_hd__decap_3
XTAP_TAPCELL_ROW_75_1240 VGND VPWR sky130_fd_sc_hd__tapvpwrvgnd_1
XFILLER_108_492 VGND VGND VPWR VPWR sky130_fd_sc_hd__fill_1
XFILLER_123_440 VGND VGND VPWR VPWR sky130_fd_sc_hd__decap_3
XFILLER_69_505 VGND VGND VPWR VPWR sky130_fd_sc_hd__decap_3
XFILLER_69_516 VGND VGND VPWR VPWR sky130_fd_sc_hd__decap_3
XFILLER_123_473 VGND VGND VPWR VPWR sky130_fd_sc_hd__decap_3
XTAP_TAPCELL_ROW_9_380 VGND VPWR sky130_fd_sc_hd__tapvpwrvgnd_1
XFILLER_111_635 VGND VGND VPWR VPWR sky130_fd_sc_hd__decap_3
XFILLER_96_335 VGND VGND VPWR VPWR sky130_fd_sc_hd__decap_3
XFILLER_111_668 VGND VGND VPWR VPWR sky130_fd_sc_hd__decap_3
XPHY_EDGE_ROW_10_Right_10 VGND VGND VPWR VPWR sky130_fd_sc_hd__decap_3
XFILLER_96_368 VGND VGND VPWR VPWR sky130_fd_sc_hd__fill_1
XFILLER_49_240 VGND VGND VPWR VPWR sky130_fd_sc_hd__decap_3
XFILLER_111_679 VGND VGND VPWR VPWR sky130_fd_sc_hd__decap_3
XFILLER_65_700 VGND VGND VPWR VPWR sky130_fd_sc_hd__decap_3
XFILLER_110_156 VGND VGND VPWR VPWR sky130_fd_sc_hd__decap_3
XFILLER_2_75 VGND VGND VPWR VPWR sky130_fd_sc_hd__fill_1
XFILLER_49_284 VGND VGND VPWR VPWR sky130_fd_sc_hd__decap_3
XFILLER_37_435 VGND VGND VPWR VPWR sky130_fd_sc_hd__decap_3
XFILLER_92_530 VGND VGND VPWR VPWR sky130_fd_sc_hd__fill_2
XFILLER_64_221 VGND VGND VPWR VPWR sky130_fd_sc_hd__decap_3
XFILLER_37_468 VGND VGND VPWR VPWR sky130_fd_sc_hd__decap_3
XFILLER_92_574 VGND VGND VPWR VPWR sky130_fd_sc_hd__decap_3
XFILLER_64_265 VGND VGND VPWR VPWR sky130_fd_sc_hd__decap_3
XFILLER_37_479 VGND VGND VPWR VPWR sky130_fd_sc_hd__decap_3
XFILLER_80_725 VGND VGND VPWR VPWR sky130_fd_sc_hd__decap_3
XFILLER_18_660 VGND VGND VPWR VPWR sky130_fd_sc_hd__decap_3
XFILLER_52_427 VGND VGND VPWR VPWR sky130_fd_sc_hd__decap_3
XFILLER_18_693 VGND VGND VPWR VPWR sky130_fd_sc_hd__decap_3
XTAP_TAPCELL_ROW_86_1380 VGND VPWR sky130_fd_sc_hd__tapvpwrvgnd_1
X_4932_ _4910_/A _4927_/X _4929_/Y _6996_/D _4997_/A1 VGND VGND VPWR VPWR _4932_/X
+ sky130_fd_sc_hd__a32o_2
XFILLER_52_449 VGND VGND VPWR VPWR sky130_fd_sc_hd__decap_3
XTAP_TAPCELL_ROW_86_1391 VGND VPWR sky130_fd_sc_hd__tapvpwrvgnd_1
XFILLER_33_641 VGND VGND VPWR VPWR sky130_fd_sc_hd__decap_3
XFILLER_17_192 VGND VGND VPWR VPWR sky130_fd_sc_hd__decap_3
XFILLER_33_685 VGND VGND VPWR VPWR sky130_fd_sc_hd__decap_3
XFILLER_32_173 VGND VGND VPWR VPWR sky130_fd_sc_hd__fill_2
XANTENNA_14 _4961_/A VGND VGND VPWR VPWR sky130_fd_sc_hd__diode_2
X_6602_ _6602_/A VGND VGND VPWR VPWR _6602_/Y sky130_fd_sc_hd__inv_2
X_3814_ _7391_/Q _4791_/A1 _3813_/Y VGND VGND VPWR VPWR _7391_/D sky130_fd_sc_hd__a21bo_2
XFILLER_20_357 VGND VGND VPWR VPWR sky130_fd_sc_hd__decap_3
XFILLER_119_724 VGND VGND VPWR VPWR sky130_fd_sc_hd__decap_3
X_6533_ _6630_/A VGND VGND VPWR VPWR _6533_/Y sky130_fd_sc_hd__inv_2
XFILLER_20_379 VGND VGND VPWR VPWR sky130_fd_sc_hd__decap_3
X_3745_ _6978_/Q _3893_/A2 _3892_/B1 _6723_/Q _3744_/X VGND VGND VPWR VPWR _3745_/X
+ sky130_fd_sc_hd__a221o_2
XFILLER_118_245 VGND VGND VPWR VPWR sky130_fd_sc_hd__decap_3
X_6464_ _6591_/A VGND VGND VPWR VPWR _6464_/Y sky130_fd_sc_hd__inv_2
X_3676_ _6716_/Q VGND VGND VPWR VPWR _3676_/Y sky130_fd_sc_hd__inv_2
XFILLER_106_418 VGND VGND VPWR VPWR sky130_fd_sc_hd__fill_2
X_5415_ _5415_/A0 _5121_/X _5429_/S VGND VGND VPWR VPWR _7126_/D sky130_fd_sc_hd__mux2_2
X_6395_ _6620_/A VGND VGND VPWR VPWR _6395_/Y sky130_fd_sc_hd__inv_2
X_5346_ _5346_/A0 _5121_/X _7412_/A VGND VGND VPWR VPWR _7158_/D sky130_fd_sc_hd__mux2_2
XFILLER_0_707 VGND VGND VPWR VPWR sky130_fd_sc_hd__decap_3
XFILLER_87_302 VGND VGND VPWR VPWR sky130_fd_sc_hd__decap_3
XFILLER_114_473 VGND VGND VPWR VPWR sky130_fd_sc_hd__decap_3
XFILLER_102_613 VGND VGND VPWR VPWR sky130_fd_sc_hd__decap_3
XFILLER_0_729 VGND VGND VPWR VPWR sky130_fd_sc_hd__decap_3
XFILLER_99_184 VGND VGND VPWR VPWR sky130_fd_sc_hd__decap_3
XFILLER_102_657 VGND VGND VPWR VPWR sky130_fd_sc_hd__decap_3
X_7016_ _7356_/CLK _7016_/D _6296_/Y VGND VGND VPWR VPWR _7016_/Q sky130_fd_sc_hd__dfrtp_2
XFILLER_87_368 VGND VGND VPWR VPWR sky130_fd_sc_hd__fill_2
X_4228_ _7014_/Q _4601_/S _3975_/S _7195_/Q _4227_/X VGND VGND VPWR VPWR _4228_/X
+ sky130_fd_sc_hd__a221o_2
XFILLER_56_722 VGND VGND VPWR VPWR sky130_fd_sc_hd__decap_3
XFILLER_101_189 VGND VGND VPWR VPWR sky130_fd_sc_hd__decap_3
X_4159_ _7329_/Q _3958_/S _4268_/B1 _7361_/Q _4347_/C1 VGND VGND VPWR VPWR _4159_/X
+ sky130_fd_sc_hd__a221o_2
XFILLER_110_690 VGND VGND VPWR VPWR sky130_fd_sc_hd__decap_3
XFILLER_83_530 VGND VGND VPWR VPWR sky130_fd_sc_hd__decap_3
XPHY_EDGE_ROW_106_Right_106 VGND VGND VPWR VPWR sky130_fd_sc_hd__decap_3
XFILLER_71_703 VGND VGND VPWR VPWR sky130_fd_sc_hd__decap_3
XFILLER_28_468 VGND VGND VPWR VPWR sky130_fd_sc_hd__decap_3
XFILLER_16_619 VGND VGND VPWR VPWR sky130_fd_sc_hd__decap_3
XTAP_TAPCELL_ROW_26_603 VGND VPWR sky130_fd_sc_hd__tapvpwrvgnd_1
XFILLER_83_585 VGND VGND VPWR VPWR sky130_fd_sc_hd__decap_3
XFILLER_55_276 VGND VGND VPWR VPWR sky130_fd_sc_hd__decap_3
XFILLER_43_449 VGND VGND VPWR VPWR sky130_fd_sc_hd__decap_3
Xclkbuf_leaf_35_clk clkbuf_leaf_2_clk/A VGND VGND VPWR VPWR _7352_/CLK sky130_fd_sc_hd__clkbuf_16
XFILLER_62_14 VGND VGND VPWR VPWR sky130_fd_sc_hd__fill_1
XTAP_TAPCELL_ROW_54_967 VGND VPWR sky130_fd_sc_hd__tapvpwrvgnd_1
XFILLER_24_663 VGND VGND VPWR VPWR sky130_fd_sc_hd__decap_3
XFILLER_23_140 VGND VGND VPWR VPWR sky130_fd_sc_hd__decap_3
XFILLER_24_696 VGND VGND VPWR VPWR sky130_fd_sc_hd__decap_3
XFILLER_51_482 VGND VGND VPWR VPWR sky130_fd_sc_hd__fill_1
XFILLER_11_346 VGND VGND VPWR VPWR sky130_fd_sc_hd__decap_3
XFILLER_7_317 VGND VGND VPWR VPWR sky130_fd_sc_hd__decap_3
XFILLER_3_501 VGND VGND VPWR VPWR sky130_fd_sc_hd__decap_3
XFILLER_3_523 VGND VGND VPWR VPWR sky130_fd_sc_hd__decap_3
XFILLER_11_73 VGND VGND VPWR VPWR sky130_fd_sc_hd__decap_3
XTAP_TAPCELL_ROW_111_1705 VGND VPWR sky130_fd_sc_hd__tapvpwrvgnd_1
XFILLER_3_556 VGND VGND VPWR VPWR sky130_fd_sc_hd__decap_3
XTAP_TAPCELL_ROW_111_1716 VGND VPWR sky130_fd_sc_hd__tapvpwrvgnd_1
XFILLER_3_567 VGND VGND VPWR VPWR sky130_fd_sc_hd__decap_3
XFILLER_87_33 VGND VGND VPWR VPWR sky130_fd_sc_hd__decap_3
XTAP_TAPCELL_ROW_6_350 VGND VPWR sky130_fd_sc_hd__tapvpwrvgnd_1
XFILLER_87_88 VGND VGND VPWR VPWR sky130_fd_sc_hd__decap_3
XFILLER_66_508 VGND VGND VPWR VPWR sky130_fd_sc_hd__decap_3
XFILLER_47_700 VGND VGND VPWR VPWR sky130_fd_sc_hd__decap_3
XFILLER_19_402 VGND VGND VPWR VPWR sky130_fd_sc_hd__decap_3
XTAP_TAPCELL_ROW_70_1181 VGND VPWR sky130_fd_sc_hd__tapvpwrvgnd_1
XFILLER_120_498 VGND VGND VPWR VPWR sky130_fd_sc_hd__decap_3
XFILLER_46_210 VGND VGND VPWR VPWR sky130_fd_sc_hd__decap_3
XFILLER_19_424 VGND VGND VPWR VPWR sky130_fd_sc_hd__fill_2
XFILLER_93_349 VGND VGND VPWR VPWR sky130_fd_sc_hd__decap_3
XFILLER_74_530 VGND VGND VPWR VPWR sky130_fd_sc_hd__fill_2
XFILLER_74_541 VGND VGND VPWR VPWR sky130_fd_sc_hd__decap_3
XFILLER_46_243 VGND VGND VPWR VPWR sky130_fd_sc_hd__decap_3
XTAP_TAPCELL_ROW_109_1678 VGND VPWR sky130_fd_sc_hd__tapvpwrvgnd_1
XFILLER_46_265 VGND VGND VPWR VPWR sky130_fd_sc_hd__decap_3
XTAP_TAPCELL_ROW_109_1689 VGND VPWR sky130_fd_sc_hd__tapvpwrvgnd_1
XFILLER_62_725 VGND VGND VPWR VPWR sky130_fd_sc_hd__decap_3
XFILLER_36_70 VGND VGND VPWR VPWR sky130_fd_sc_hd__decap_3
XFILLER_46_298 VGND VGND VPWR VPWR sky130_fd_sc_hd__decap_3
Xclkbuf_leaf_26_clk clkbuf_3_6__f_clk/X VGND VGND VPWR VPWR _7360_/CLK sky130_fd_sc_hd__clkbuf_16
XFILLER_61_246 VGND VGND VPWR VPWR sky130_fd_sc_hd__decap_3
XFILLER_15_641 VGND VGND VPWR VPWR sky130_fd_sc_hd__decap_3
XTAP_TAPCELL_ROW_122_1856 VGND VPWR sky130_fd_sc_hd__tapvpwrvgnd_1
XFILLER_15_685 VGND VGND VPWR VPWR sky130_fd_sc_hd__decap_3
XFILLER_30_622 VGND VGND VPWR VPWR sky130_fd_sc_hd__decap_3
XFILLER_42_493 VGND VGND VPWR VPWR sky130_fd_sc_hd__decap_3
XFILLER_30_666 VGND VGND VPWR VPWR sky130_fd_sc_hd__decap_3
XFILLER_30_699 VGND VGND VPWR VPWR sky130_fd_sc_hd__fill_1
XFILLER_116_716 VGND VGND VPWR VPWR sky130_fd_sc_hd__decap_3
Xhold807 _6962_/Q VGND VGND VPWR VPWR _6962_/D sky130_fd_sc_hd__dlygate4sd3_1
Xhold818 _6861_/Q VGND VGND VPWR VPWR _6861_/D sky130_fd_sc_hd__dlygate4sd3_1
X_3461_ _7281_/Q _4532_/S _4348_/A2 _7153_/Q _3460_/X VGND VGND VPWR VPWR _3461_/X
+ sky130_fd_sc_hd__a221o_2
Xhold829 _6737_/Q VGND VGND VPWR VPWR _6737_/D sky130_fd_sc_hd__dlygate4sd3_1
Xmax_cap559 _4282_/Y VGND VGND VPWR VPWR _4612_/A sky130_fd_sc_hd__buf_2
X_5200_ _5200_/A _5200_/B VGND VGND VPWR VPWR _7228_/D sky130_fd_sc_hd__and2_2
X_3392_ _3429_/A _3429_/B VGND VGND VPWR VPWR _3591_/A sky130_fd_sc_hd__nor2_2
XFILLER_97_600 VGND VGND VPWR VPWR sky130_fd_sc_hd__decap_3
X_5131_ _3992_/Y _5128_/Y _6982_/D _5156_/S VGND VGND VPWR VPWR _5131_/X sky130_fd_sc_hd__o22a_2
XFILLER_69_324 VGND VGND VPWR VPWR sky130_fd_sc_hd__decap_3
XFILLER_97_644 VGND VGND VPWR VPWR sky130_fd_sc_hd__decap_3
XFILLER_123_281 VGND VGND VPWR VPWR sky130_fd_sc_hd__decap_3
XFILLER_111_421 VGND VGND VPWR VPWR sky130_fd_sc_hd__decap_3
XFILLER_97_688 VGND VGND VPWR VPWR sky130_fd_sc_hd__decap_3
XFILLER_57_519 VGND VGND VPWR VPWR sky130_fd_sc_hd__decap_3
XFILLER_96_176 VGND VGND VPWR VPWR sky130_fd_sc_hd__fill_1
XFILLER_111_476 VGND VGND VPWR VPWR sky130_fd_sc_hd__decap_3
XFILLER_38_722 VGND VGND VPWR VPWR sky130_fd_sc_hd__decap_3
XFILLER_84_338 VGND VGND VPWR VPWR sky130_fd_sc_hd__decap_3
XFILLER_37_243 VGND VGND VPWR VPWR sky130_fd_sc_hd__decap_3
XFILLER_53_703 VGND VGND VPWR VPWR sky130_fd_sc_hd__decap_3
XFILLER_37_265 VGND VGND VPWR VPWR sky130_fd_sc_hd__decap_3
XFILLER_37_287 VGND VGND VPWR VPWR sky130_fd_sc_hd__decap_3
XFILLER_25_427 VGND VGND VPWR VPWR sky130_fd_sc_hd__decap_3
XFILLER_16_29 VGND VGND VPWR VPWR sky130_fd_sc_hd__fill_1
XFILLER_80_544 VGND VGND VPWR VPWR sky130_fd_sc_hd__decap_3
Xclkbuf_leaf_17_clk clkload3/A VGND VGND VPWR VPWR _7406_/CLK sky130_fd_sc_hd__clkbuf_16
XFILLER_80_577 VGND VGND VPWR VPWR sky130_fd_sc_hd__fill_2
XTAP_TAPCELL_ROW_51_926 VGND VPWR sky130_fd_sc_hd__tapvpwrvgnd_1
XFILLER_33_493 VGND VGND VPWR VPWR sky130_fd_sc_hd__decap_3
XFILLER_21_644 VGND VGND VPWR VPWR sky130_fd_sc_hd__decap_3
X_4846_ _4903_/A _4890_/B VGND VGND VPWR VPWR _4884_/A sky130_fd_sc_hd__nand2_2
XFILLER_20_132 VGND VGND VPWR VPWR sky130_fd_sc_hd__decap_3
XFILLER_21_688 VGND VGND VPWR VPWR sky130_fd_sc_hd__decap_3
XTAP_TAPCELL_ROW_31_672 VGND VPWR sky130_fd_sc_hd__tapvpwrvgnd_1
X_4777_ _5015_/A _4777_/B _4777_/C VGND VGND VPWR VPWR _4777_/X sky130_fd_sc_hd__and3_2
XFILLER_119_532 VGND VGND VPWR VPWR sky130_fd_sc_hd__decap_3
XTAP_TAPCELL_ROW_99_1560 VGND VPWR sky130_fd_sc_hd__tapvpwrvgnd_1
X_6516_ _6643_/A VGND VGND VPWR VPWR _6516_/Y sky130_fd_sc_hd__inv_2
X_3728_ _3746_/A _3728_/B VGND VGND VPWR VPWR _3728_/Y sky130_fd_sc_hd__nor2_2
XFILLER_4_309 VGND VGND VPWR VPWR sky130_fd_sc_hd__decap_3
XFILLER_119_576 VGND VGND VPWR VPWR sky130_fd_sc_hd__decap_3
XFILLER_113_9 VGND VGND VPWR VPWR sky130_fd_sc_hd__decap_3
XFILLER_107_727 VGND VGND VPWR VPWR sky130_fd_sc_hd__fill_1
XFILLER_106_215 VGND VGND VPWR VPWR sky130_fd_sc_hd__fill_1
X_6447_ _6643_/A VGND VGND VPWR VPWR _6447_/Y sky130_fd_sc_hd__inv_2
XFILLER_106_237 VGND VGND VPWR VPWR sky130_fd_sc_hd__decap_3
XFILLER_106_259 VGND VGND VPWR VPWR sky130_fd_sc_hd__decap_3
XFILLER_122_719 VGND VGND VPWR VPWR sky130_fd_sc_hd__decap_3
X_6378_ _6570_/A VGND VGND VPWR VPWR _6378_/Y sky130_fd_sc_hd__inv_2
XFILLER_88_622 VGND VGND VPWR VPWR sky130_fd_sc_hd__decap_3
XFILLER_102_410 VGND VGND VPWR VPWR sky130_fd_sc_hd__decap_3
X_5329_ _5329_/A0 _4997_/X _5340_/S VGND VGND VPWR VPWR _7166_/D sky130_fd_sc_hd__mux2_2
XFILLER_0_548 VGND VGND VPWR VPWR sky130_fd_sc_hd__fill_1
XFILLER_88_666 VGND VGND VPWR VPWR sky130_fd_sc_hd__decap_3
XFILLER_87_143 VGND VGND VPWR VPWR sky130_fd_sc_hd__decap_3
XFILLER_29_700 VGND VGND VPWR VPWR sky130_fd_sc_hd__decap_3
XFILLER_88_699 VGND VGND VPWR VPWR sky130_fd_sc_hd__fill_1
XFILLER_28_221 VGND VGND VPWR VPWR sky130_fd_sc_hd__decap_3
XFILLER_113_42 VGND VGND VPWR VPWR sky130_fd_sc_hd__decap_3
XFILLER_28_265 VGND VGND VPWR VPWR sky130_fd_sc_hd__fill_2
XTAP_TAPCELL_ROW_39_772 VGND VPWR sky130_fd_sc_hd__tapvpwrvgnd_1
XFILLER_73_24 VGND VGND VPWR VPWR sky130_fd_sc_hd__decap_3
XFILLER_56_585 VGND VGND VPWR VPWR sky130_fd_sc_hd__decap_3
XFILLER_44_725 VGND VGND VPWR VPWR sky130_fd_sc_hd__decap_3
XFILLER_16_416 VGND VGND VPWR VPWR sky130_fd_sc_hd__decap_3
XFILLER_113_75 VGND VGND VPWR VPWR sky130_fd_sc_hd__decap_3
XFILLER_71_522 VGND VGND VPWR VPWR sky130_fd_sc_hd__decap_3
XFILLER_43_213 VGND VGND VPWR VPWR sky130_fd_sc_hd__decap_3
XFILLER_28_298 VGND VGND VPWR VPWR sky130_fd_sc_hd__decap_3
XFILLER_83_393 VGND VGND VPWR VPWR sky130_fd_sc_hd__decap_3
XFILLER_43_246 VGND VGND VPWR VPWR sky130_fd_sc_hd__decap_3
XFILLER_24_471 VGND VGND VPWR VPWR sky130_fd_sc_hd__decap_3
XFILLER_12_622 VGND VGND VPWR VPWR sky130_fd_sc_hd__decap_3
XFILLER_8_604 VGND VGND VPWR VPWR sky130_fd_sc_hd__decap_3
XFILLER_12_666 VGND VGND VPWR VPWR sky130_fd_sc_hd__decap_3
XFILLER_8_637 VGND VGND VPWR VPWR sky130_fd_sc_hd__decap_3
XFILLER_11_165 VGND VGND VPWR VPWR sky130_fd_sc_hd__decap_3
XFILLER_8_648 VGND VGND VPWR VPWR sky130_fd_sc_hd__decap_3
XFILLER_12_699 VGND VGND VPWR VPWR sky130_fd_sc_hd__fill_1
XFILLER_7_169 VGND VGND VPWR VPWR sky130_fd_sc_hd__decap_3
XFILLER_22_83 VGND VGND VPWR VPWR sky130_fd_sc_hd__fill_1
XTAP_TAPCELL_ROW_59_1032 VGND VPWR sky130_fd_sc_hd__tapvpwrvgnd_1
XFILLER_22_94 VGND VGND VPWR VPWR sky130_fd_sc_hd__decap_3
XFILLER_98_32 VGND VGND VPWR VPWR sky130_fd_sc_hd__decap_3
XFILLER_98_408 VGND VGND VPWR VPWR sky130_fd_sc_hd__decap_3
XFILLER_98_76 VGND VGND VPWR VPWR sky130_fd_sc_hd__decap_3
XFILLER_79_600 VGND VGND VPWR VPWR sky130_fd_sc_hd__decap_3
XFILLER_3_364 VGND VGND VPWR VPWR sky130_fd_sc_hd__decap_3
XFILLER_79_644 VGND VGND VPWR VPWR sky130_fd_sc_hd__decap_3
XFILLER_78_121 VGND VGND VPWR VPWR sky130_fd_sc_hd__decap_3
XFILLER_105_281 VGND VGND VPWR VPWR sky130_fd_sc_hd__fill_2
XFILLER_39_508 VGND VGND VPWR VPWR sky130_fd_sc_hd__decap_3
XFILLER_120_240 VGND VGND VPWR VPWR sky130_fd_sc_hd__decap_3
XFILLER_79_688 VGND VGND VPWR VPWR sky130_fd_sc_hd__decap_3
XFILLER_78_165 VGND VGND VPWR VPWR sky130_fd_sc_hd__fill_2
XFILLER_66_305 VGND VGND VPWR VPWR sky130_fd_sc_hd__decap_3
XFILLER_94_625 VGND VGND VPWR VPWR sky130_fd_sc_hd__decap_3
XFILLER_93_113 VGND VGND VPWR VPWR sky130_fd_sc_hd__decap_3
XFILLER_66_327 VGND VGND VPWR VPWR sky130_fd_sc_hd__decap_3
XFILLER_66_349 VGND VGND VPWR VPWR sky130_fd_sc_hd__fill_1
XFILLER_19_221 VGND VGND VPWR VPWR sky130_fd_sc_hd__decap_3
XFILLER_94_669 VGND VGND VPWR VPWR sky130_fd_sc_hd__decap_3
XFILLER_19_243 VGND VGND VPWR VPWR sky130_fd_sc_hd__fill_1
XFILLER_35_703 VGND VGND VPWR VPWR sky130_fd_sc_hd__decap_3
XFILLER_81_319 VGND VGND VPWR VPWR sky130_fd_sc_hd__fill_1
XFILLER_47_80 VGND VGND VPWR VPWR sky130_fd_sc_hd__decap_3
XFILLER_74_360 VGND VGND VPWR VPWR sky130_fd_sc_hd__decap_3
XFILLER_74_371 VGND VGND VPWR VPWR sky130_fd_sc_hd__decap_3
XFILLER_34_213 VGND VGND VPWR VPWR sky130_fd_sc_hd__decap_3
XFILLER_19_298 VGND VGND VPWR VPWR sky130_fd_sc_hd__decap_3
XFILLER_62_544 VGND VGND VPWR VPWR sky130_fd_sc_hd__fill_1
XFILLER_22_408 VGND VGND VPWR VPWR sky130_fd_sc_hd__decap_3
XTAP_TAPCELL_ROW_83_1350 VGND VPWR sky130_fd_sc_hd__tapvpwrvgnd_1
XFILLER_34_268 VGND VGND VPWR VPWR sky130_fd_sc_hd__decap_3
XFILLER_50_728 VGND VGND VPWR VPWR sky130_fd_sc_hd__decap_3
XFILLER_62_599 VGND VGND VPWR VPWR sky130_fd_sc_hd__decap_3
XTAP_TAPCELL_ROW_17_488 VGND VPWR sky130_fd_sc_hd__tapvpwrvgnd_1
X_4700_ _6988_/Q _5066_/A VGND VGND VPWR VPWR _5044_/A sky130_fd_sc_hd__and2_2
XFILLER_15_493 VGND VGND VPWR VPWR sky130_fd_sc_hd__decap_3
X_5680_ _7346_/Q hold924/X _5712_/S VGND VGND VPWR VPWR _6690_/D sky130_fd_sc_hd__mux2_2
XFILLER_30_452 VGND VGND VPWR VPWR sky130_fd_sc_hd__decap_3
XPHY_EDGE_ROW_7_Left_131 VGND VGND VPWR VPWR sky130_fd_sc_hd__decap_3
X_4631_ _5003_/A _4277_/B _4630_/X _4273_/Y VGND VGND VPWR VPWR _4631_/X sky130_fd_sc_hd__a31o_2
X_7350_ _7352_/CLK _7350_/D _6630_/Y VGND VGND VPWR VPWR _7350_/Q sky130_fd_sc_hd__dfrtp_2
X_6301_ _6608_/A VGND VGND VPWR VPWR _6301_/Y sky130_fd_sc_hd__inv_2
Xhold604 _6851_/Q VGND VGND VPWR VPWR _6851_/D sky130_fd_sc_hd__dlygate4sd3_1
XFILLER_116_524 VGND VGND VPWR VPWR sky130_fd_sc_hd__decap_3
Xhold615 _6758_/Q VGND VGND VPWR VPWR _6758_/D sky130_fd_sc_hd__dlygate4sd3_1
Xhold626 _6762_/Q VGND VGND VPWR VPWR _6762_/D sky130_fd_sc_hd__dlygate4sd3_1
X_7281_ _7352_/CLK _7281_/D _6561_/Y VGND VGND VPWR VPWR _7281_/Q sky130_fd_sc_hd__dfrtp_2
X_4493_ _4493_/A0 _7301_/Q _4497_/S VGND VGND VPWR VPWR _7333_/D sky130_fd_sc_hd__mux2_2
Xhold637 _6819_/Q VGND VGND VPWR VPWR _6819_/D sky130_fd_sc_hd__dlygate4sd3_1
XFILLER_116_557 VGND VGND VPWR VPWR sky130_fd_sc_hd__decap_3
Xhold648 _6785_/Q VGND VGND VPWR VPWR _6785_/D sky130_fd_sc_hd__dlygate4sd3_1
XFILLER_89_408 VGND VGND VPWR VPWR sky130_fd_sc_hd__fill_1
XFILLER_6_191 VGND VGND VPWR VPWR sky130_fd_sc_hd__fill_2
Xhold659 _6946_/Q VGND VGND VPWR VPWR _6946_/D sky130_fd_sc_hd__dlygate4sd3_1
XFILLER_104_719 VGND VGND VPWR VPWR sky130_fd_sc_hd__decap_3
Xclkbuf_leaf_6_clk clkbuf_leaf_9_clk/A VGND VGND VPWR VPWR _6926_/CLK sky130_fd_sc_hd__clkbuf_16
XTAP_TAPCELL_ROW_94_1490 VGND VPWR sky130_fd_sc_hd__tapvpwrvgnd_1
X_3375_ _5118_/A _3399_/B VGND VGND VPWR VPWR _5641_/A sky130_fd_sc_hd__nand2_2
XFILLER_97_452 VGND VGND VPWR VPWR sky130_fd_sc_hd__decap_3
X_5114_ _5114_/A _5114_/B VGND VGND VPWR VPWR _5114_/Y sky130_fd_sc_hd__nand2_2
XFILLER_85_603 VGND VGND VPWR VPWR sky130_fd_sc_hd__decap_3
XFILLER_111_262 VGND VGND VPWR VPWR sky130_fd_sc_hd__decap_3
XFILLER_84_113 VGND VGND VPWR VPWR sky130_fd_sc_hd__fill_1
XFILLER_69_187 VGND VGND VPWR VPWR sky130_fd_sc_hd__decap_3
XFILLER_85_647 VGND VGND VPWR VPWR sky130_fd_sc_hd__decap_3
XFILLER_111_284 VGND VGND VPWR VPWR sky130_fd_sc_hd__decap_3
X_5045_ _6988_/Q _5045_/B VGND VGND VPWR VPWR _5045_/X sky130_fd_sc_hd__or2_2
XFILLER_84_179 VGND VGND VPWR VPWR sky130_fd_sc_hd__fill_2
XFILLER_53_500 VGND VGND VPWR VPWR sky130_fd_sc_hd__decap_3
XFILLER_38_585 VGND VGND VPWR VPWR sky130_fd_sc_hd__decap_3
XFILLER_26_725 VGND VGND VPWR VPWR sky130_fd_sc_hd__decap_3
XFILLER_65_371 VGND VGND VPWR VPWR sky130_fd_sc_hd__decap_3
XFILLER_93_691 VGND VGND VPWR VPWR sky130_fd_sc_hd__decap_3
XTAP_TAPCELL_ROW_36_731 VGND VPWR sky130_fd_sc_hd__tapvpwrvgnd_1
X_6996_ _7395_/CLK _6996_/D _6276_/Y VGND VGND VPWR VPWR _6996_/Q sky130_fd_sc_hd__dfrtp_2
XFILLER_41_706 VGND VGND VPWR VPWR sky130_fd_sc_hd__decap_3
XFILLER_13_408 VGND VGND VPWR VPWR sky130_fd_sc_hd__fill_2
XFILLER_25_279 VGND VGND VPWR VPWR sky130_fd_sc_hd__fill_1
XFILLER_13_419 VGND VGND VPWR VPWR sky130_fd_sc_hd__decap_3
XFILLER_40_238 VGND VGND VPWR VPWR sky130_fd_sc_hd__decap_3
XFILLER_21_441 VGND VGND VPWR VPWR sky130_fd_sc_hd__decap_3
XFILLER_21_452 VGND VGND VPWR VPWR sky130_fd_sc_hd__fill_1
X_4829_ _4829_/A _4829_/B VGND VGND VPWR VPWR _4829_/Y sky130_fd_sc_hd__nor2_2
XFILLER_119_340 VGND VGND VPWR VPWR sky130_fd_sc_hd__decap_3
XFILLER_5_629 VGND VGND VPWR VPWR sky130_fd_sc_hd__decap_3
XFILLER_111_6 VGND VGND VPWR VPWR sky130_fd_sc_hd__decap_3
XFILLER_107_535 VGND VGND VPWR VPWR sky130_fd_sc_hd__decap_3
XFILLER_108_20 VGND VGND VPWR VPWR sky130_fd_sc_hd__decap_3
XFILLER_107_579 VGND VGND VPWR VPWR sky130_fd_sc_hd__decap_3
XFILLER_122_516 VGND VGND VPWR VPWR sky130_fd_sc_hd__decap_3
XFILLER_68_35 VGND VGND VPWR VPWR sky130_fd_sc_hd__decap_3
XFILLER_0_323 VGND VGND VPWR VPWR sky130_fd_sc_hd__decap_3
XFILLER_0_345 VGND VGND VPWR VPWR sky130_fd_sc_hd__decap_3
XFILLER_88_463 VGND VGND VPWR VPWR sky130_fd_sc_hd__decap_3
XFILLER_76_625 VGND VGND VPWR VPWR sky130_fd_sc_hd__decap_3
XFILLER_75_113 VGND VGND VPWR VPWR sky130_fd_sc_hd__fill_1
XFILLER_48_327 VGND VGND VPWR VPWR sky130_fd_sc_hd__decap_3
XFILLER_102_295 VGND VGND VPWR VPWR sky130_fd_sc_hd__decap_3
XFILLER_76_669 VGND VGND VPWR VPWR sky130_fd_sc_hd__decap_3
XFILLER_91_606 VGND VGND VPWR VPWR sky130_fd_sc_hd__decap_3
XFILLER_91_617 VGND VGND VPWR VPWR sky130_fd_sc_hd__decap_3
XFILLER_63_308 VGND VGND VPWR VPWR sky130_fd_sc_hd__fill_1
XFILLER_17_703 VGND VGND VPWR VPWR sky130_fd_sc_hd__decap_3
XFILLER_84_56 VGND VGND VPWR VPWR sky130_fd_sc_hd__decap_3
XFILLER_90_105 VGND VGND VPWR VPWR sky130_fd_sc_hd__decap_3
XFILLER_29_574 VGND VGND VPWR VPWR sky130_fd_sc_hd__decap_3
XFILLER_56_371 VGND VGND VPWR VPWR sky130_fd_sc_hd__decap_3
Xplace308 _4361_/A VGND VGND VPWR VPWR _5086_/A sky130_fd_sc_hd__buf_2
XFILLER_44_522 VGND VGND VPWR VPWR sky130_fd_sc_hd__fill_2
XFILLER_16_213 VGND VGND VPWR VPWR sky130_fd_sc_hd__decap_3
Xplace319 _4537_/X VGND VGND VPWR VPWR _4577_/B sky130_fd_sc_hd__buf_2
XFILLER_56_393 VGND VGND VPWR VPWR sky130_fd_sc_hd__decap_3
XTAP_TAPCELL_ROW_106_1648 VGND VPWR sky130_fd_sc_hd__tapvpwrvgnd_1
XFILLER_44_544 VGND VGND VPWR VPWR sky130_fd_sc_hd__decap_3
XFILLER_16_246 VGND VGND VPWR VPWR sky130_fd_sc_hd__decap_3
XFILLER_44_577 VGND VGND VPWR VPWR sky130_fd_sc_hd__decap_3
XFILLER_71_363 VGND VGND VPWR VPWR sky130_fd_sc_hd__decap_3
XFILLER_32_728 VGND VGND VPWR VPWR sky130_fd_sc_hd__decap_3
XFILLER_31_205 VGND VGND VPWR VPWR sky130_fd_sc_hd__decap_3
XFILLER_31_249 VGND VGND VPWR VPWR sky130_fd_sc_hd__decap_3
XTAP_TAPCELL_ROW_14_447 VGND VPWR sky130_fd_sc_hd__tapvpwrvgnd_1
XFILLER_8_401 VGND VGND VPWR VPWR sky130_fd_sc_hd__decap_3
XFILLER_12_452 VGND VGND VPWR VPWR sky130_fd_sc_hd__decap_3
XFILLER_12_474 VGND VGND VPWR VPWR sky130_fd_sc_hd__fill_2
XFILLER_8_467 VGND VGND VPWR VPWR sky130_fd_sc_hd__decap_3
XFILLER_99_706 VGND VGND VPWR VPWR sky130_fd_sc_hd__decap_3
XFILLER_4_640 VGND VGND VPWR VPWR sky130_fd_sc_hd__decap_3
XTAP_TAPCELL_ROW_117_1788 VGND VPWR sky130_fd_sc_hd__tapvpwrvgnd_1
XFILLER_4_651 VGND VGND VPWR VPWR sky130_fd_sc_hd__decap_3
XFILLER_113_505 VGND VGND VPWR VPWR sky130_fd_sc_hd__decap_3
XFILLER_4_684 VGND VGND VPWR VPWR sky130_fd_sc_hd__decap_3
XFILLER_113_538 VGND VGND VPWR VPWR sky130_fd_sc_hd__decap_3
XFILLER_3_172 VGND VGND VPWR VPWR sky130_fd_sc_hd__fill_1
XFILLER_67_603 VGND VGND VPWR VPWR sky130_fd_sc_hd__decap_3
XFILLER_121_582 VGND VGND VPWR VPWR sky130_fd_sc_hd__decap_3
XFILLER_67_647 VGND VGND VPWR VPWR sky130_fd_sc_hd__decap_3
XFILLER_94_433 VGND VGND VPWR VPWR sky130_fd_sc_hd__decap_3
XFILLER_94_477 VGND VGND VPWR VPWR sky130_fd_sc_hd__decap_3
XFILLER_82_628 VGND VGND VPWR VPWR sky130_fd_sc_hd__decap_3
XFILLER_81_127 VGND VGND VPWR VPWR sky130_fd_sc_hd__decap_3
XFILLER_75_691 VGND VGND VPWR VPWR sky130_fd_sc_hd__decap_3
X_6850_ clkload4/A _6850_/D VGND VGND VPWR VPWR _6850_/Q sky130_fd_sc_hd__dfxtp_2
XFILLER_23_706 VGND VGND VPWR VPWR sky130_fd_sc_hd__decap_3
XFILLER_90_672 VGND VGND VPWR VPWR sky130_fd_sc_hd__decap_3
XFILLER_62_363 VGND VGND VPWR VPWR sky130_fd_sc_hd__fill_1
XTAP_TAPCELL_ROW_33_701 VGND VPWR sky130_fd_sc_hd__tapvpwrvgnd_1
XFILLER_35_588 VGND VGND VPWR VPWR sky130_fd_sc_hd__decap_3
XPHY_EDGE_ROW_8_Right_8 VGND VGND VPWR VPWR sky130_fd_sc_hd__decap_3
X_6781_ _7215_/CLK _6781_/D VGND VGND VPWR VPWR _6781_/Q sky130_fd_sc_hd__dfxtp_2
XFILLER_22_216 VGND VGND VPWR VPWR sky130_fd_sc_hd__decap_3
X_3993_ _4467_/B _3919_/X _3991_/X _3992_/Y VGND VGND VPWR VPWR _3993_/X sky130_fd_sc_hd__a31o_2
XFILLER_50_536 VGND VGND VPWR VPWR sky130_fd_sc_hd__decap_3
XFILLER_22_238 VGND VGND VPWR VPWR sky130_fd_sc_hd__decap_3
X_5663_ _5663_/A _5663_/B _5663_/C _5663_/D VGND VGND VPWR VPWR _5664_/D sky130_fd_sc_hd__nor4_2
XFILLER_30_271 VGND VGND VPWR VPWR sky130_fd_sc_hd__decap_3
X_7402_ _7403_/CLK _7402_/D _6682_/Y VGND VGND VPWR VPWR _7402_/Q sky130_fd_sc_hd__dfrtp_2
X_4614_ _4614_/A _4614_/B _4614_/C _5113_/A VGND VGND VPWR VPWR _4614_/X sky130_fd_sc_hd__and4_4
X_7333_ _7365_/CLK _7333_/D _6613_/Y VGND VGND VPWR VPWR _7333_/Q sky130_fd_sc_hd__dfrtp_2
XFILLER_116_365 VGND VGND VPWR VPWR sky130_fd_sc_hd__decap_3
X_7264_ _7362_/CLK _7264_/D _6544_/Y VGND VGND VPWR VPWR _7264_/Q sky130_fd_sc_hd__dfrtp_2
X_4476_ _7341_/Q _7309_/Q _4486_/S VGND VGND VPWR VPWR _7341_/D sky130_fd_sc_hd__mux2_2
XFILLER_89_216 VGND VGND VPWR VPWR sky130_fd_sc_hd__decap_3
XFILLER_116_398 VGND VGND VPWR VPWR sky130_fd_sc_hd__decap_3
X_3427_ _3527_/A _3427_/B VGND VGND VPWR VPWR _3508_/A sky130_fd_sc_hd__nand2b_2
XFILLER_89_249 VGND VGND VPWR VPWR sky130_fd_sc_hd__decap_3
XPHY_EDGE_ROW_39_Right_39 VGND VGND VPWR VPWR sky130_fd_sc_hd__decap_3
X_7195_ _7325_/CLK _7195_/D _6475_/Y VGND VGND VPWR VPWR _7195_/Q sky130_fd_sc_hd__dfrtp_2
XFILLER_58_614 VGND VGND VPWR VPWR sky130_fd_sc_hd__decap_3
XFILLER_112_560 VGND VGND VPWR VPWR sky130_fd_sc_hd__decap_3
X_3358_ _3469_/A _3469_/B _3449_/A _6980_/Q VGND VGND VPWR VPWR _3358_/X sky130_fd_sc_hd__o211a_4
Xhold1101 _7398_/Q VGND VGND VPWR VPWR _3750_/A1 sky130_fd_sc_hd__dlygate4sd3_1
XFILLER_97_271 VGND VGND VPWR VPWR sky130_fd_sc_hd__fill_1
XFILLER_100_722 VGND VGND VPWR VPWR sky130_fd_sc_hd__decap_3
Xhold1112 _7135_/Q VGND VGND VPWR VPWR _5396_/A0 sky130_fd_sc_hd__dlygate4sd3_1
Xhold1123 _7125_/Q VGND VGND VPWR VPWR _5417_/A0 sky130_fd_sc_hd__dlygate4sd3_1
XFILLER_97_293 VGND VGND VPWR VPWR sky130_fd_sc_hd__decap_3
XFILLER_85_444 VGND VGND VPWR VPWR sky130_fd_sc_hd__decap_3
Xhold1134 _7272_/Q VGND VGND VPWR VPWR _4823_/A0 sky130_fd_sc_hd__dlygate4sd3_1
XFILLER_58_669 VGND VGND VPWR VPWR sky130_fd_sc_hd__decap_3
Xhold1145 _7146_/Q VGND VGND VPWR VPWR _5373_/A0 sky130_fd_sc_hd__dlygate4sd3_1
Xhold1156 _7328_/Q VGND VGND VPWR VPWR _4503_/A0 sky130_fd_sc_hd__dlygate4sd3_1
Xhold1167 _7017_/Q VGND VGND VPWR VPWR _5621_/A sky130_fd_sc_hd__dlygate4sd3_1
XFILLER_85_477 VGND VGND VPWR VPWR sky130_fd_sc_hd__decap_3
XFILLER_73_617 VGND VGND VPWR VPWR sky130_fd_sc_hd__decap_3
XFILLER_45_308 VGND VGND VPWR VPWR sky130_fd_sc_hd__decap_3
X_5028_ _5028_/A0 _5027_/X _5028_/S VGND VGND VPWR VPWR _7260_/D sky130_fd_sc_hd__mux2_2
Xhold1178 _7148_/Q VGND VGND VPWR VPWR _5369_/A0 sky130_fd_sc_hd__dlygate4sd3_1
XFILLER_57_179 VGND VGND VPWR VPWR sky130_fd_sc_hd__decap_3
XFILLER_38_360 VGND VGND VPWR VPWR sky130_fd_sc_hd__decap_3
Xhold1189 _7383_/Q VGND VGND VPWR VPWR _3875_/A1 sky130_fd_sc_hd__dlygate4sd3_1
XFILLER_72_127 VGND VGND VPWR VPWR sky130_fd_sc_hd__decap_3
XFILLER_38_393 VGND VGND VPWR VPWR sky130_fd_sc_hd__decap_3
XFILLER_81_650 VGND VGND VPWR VPWR sky130_fd_sc_hd__decap_3
XFILLER_41_503 VGND VGND VPWR VPWR sky130_fd_sc_hd__fill_1
XFILLER_26_577 VGND VGND VPWR VPWR sky130_fd_sc_hd__decap_3
XFILLER_14_728 VGND VGND VPWR VPWR sky130_fd_sc_hd__decap_3
XFILLER_13_205 VGND VGND VPWR VPWR sky130_fd_sc_hd__decap_3
XPHY_EDGE_ROW_48_Right_48 VGND VGND VPWR VPWR sky130_fd_sc_hd__decap_3
X_6979_ _7386_/CLK _6979_/D _6259_/Y VGND VGND VPWR VPWR _6979_/Q sky130_fd_sc_hd__dfrtp_2
XFILLER_81_694 VGND VGND VPWR VPWR sky130_fd_sc_hd__decap_3
XFILLER_80_171 VGND VGND VPWR VPWR sky130_fd_sc_hd__decap_3
XFILLER_110_21 VGND VGND VPWR VPWR sky130_fd_sc_hd__decap_3
XFILLER_41_547 VGND VGND VPWR VPWR sky130_fd_sc_hd__decap_3
XFILLER_110_32 VGND VGND VPWR VPWR sky130_fd_sc_hd__decap_3
XFILLER_13_249 VGND VGND VPWR VPWR sky130_fd_sc_hd__decap_3
XFILLER_110_65 VGND VGND VPWR VPWR sky130_fd_sc_hd__fill_1
XTAP_TAPCELL_ROW_11_406 VGND VPWR sky130_fd_sc_hd__tapvpwrvgnd_1
XTAP_TAPCELL_ROW_101_1578 VGND VPWR sky130_fd_sc_hd__tapvpwrvgnd_1
XFILLER_119_30 VGND VGND VPWR VPWR sky130_fd_sc_hd__decap_3
XFILLER_119_63 VGND VGND VPWR VPWR sky130_fd_sc_hd__decap_3
XFILLER_119_96 VGND VGND VPWR VPWR sky130_fd_sc_hd__decap_3
XFILLER_107_365 VGND VGND VPWR VPWR sky130_fd_sc_hd__decap_3
XPHY_EDGE_ROW_57_Right_57 VGND VGND VPWR VPWR sky130_fd_sc_hd__decap_3
XPHY_EDGE_ROW_79_Left_203 VGND VGND VPWR VPWR sky130_fd_sc_hd__decap_3
XFILLER_79_78 VGND VGND VPWR VPWR sky130_fd_sc_hd__decap_3
XFILLER_1_632 VGND VGND VPWR VPWR sky130_fd_sc_hd__decap_3
Xhold990 _7193_/Q VGND VGND VPWR VPWR hold990/X sky130_fd_sc_hd__dlygate4sd3_1
XFILLER_95_208 VGND VGND VPWR VPWR sky130_fd_sc_hd__decap_3
XFILLER_49_603 VGND VGND VPWR VPWR sky130_fd_sc_hd__decap_3
XFILLER_1_665 VGND VGND VPWR VPWR sky130_fd_sc_hd__decap_3
XFILLER_95_219 VGND VGND VPWR VPWR sky130_fd_sc_hd__decap_3
XFILLER_1_676 VGND VGND VPWR VPWR sky130_fd_sc_hd__decap_3
XFILLER_0_164 VGND VGND VPWR VPWR sky130_fd_sc_hd__decap_3
XFILLER_48_102 VGND VGND VPWR VPWR sky130_fd_sc_hd__fill_1
XFILLER_103_582 VGND VGND VPWR VPWR sky130_fd_sc_hd__decap_3
XFILLER_0_186 VGND VGND VPWR VPWR sky130_fd_sc_hd__fill_2
XFILLER_49_647 VGND VGND VPWR VPWR sky130_fd_sc_hd__decap_3
XFILLER_0_197 VGND VGND VPWR VPWR sky130_fd_sc_hd__decap_3
XFILLER_95_66 VGND VGND VPWR VPWR sky130_fd_sc_hd__decap_3
XFILLER_95_99 VGND VGND VPWR VPWR sky130_fd_sc_hd__decap_3
XFILLER_76_477 VGND VGND VPWR VPWR sky130_fd_sc_hd__fill_1
XFILLER_64_628 VGND VGND VPWR VPWR sky130_fd_sc_hd__decap_3
XTAP_TAPCELL_ROW_19_517 VGND VPWR sky130_fd_sc_hd__tapvpwrvgnd_1
XFILLER_63_116 VGND VGND VPWR VPWR sky130_fd_sc_hd__decap_3
XFILLER_28_82 VGND VGND VPWR VPWR sky130_fd_sc_hd__fill_2
XFILLER_57_691 VGND VGND VPWR VPWR sky130_fd_sc_hd__decap_3
XFILLER_91_447 VGND VGND VPWR VPWR sky130_fd_sc_hd__fill_1
XFILLER_63_138 VGND VGND VPWR VPWR sky130_fd_sc_hd__fill_1
XFILLER_29_393 VGND VGND VPWR VPWR sky130_fd_sc_hd__decap_3
XFILLER_91_458 VGND VGND VPWR VPWR sky130_fd_sc_hd__decap_3
XTAP_TAPCELL_ROW_67_1142 VGND VPWR sky130_fd_sc_hd__tapvpwrvgnd_1
XPHY_EDGE_ROW_66_Right_66 VGND VGND VPWR VPWR sky130_fd_sc_hd__decap_3
XPHY_EDGE_ROW_88_Left_212 VGND VGND VPWR VPWR sky130_fd_sc_hd__decap_3
XFILLER_72_672 VGND VGND VPWR VPWR sky130_fd_sc_hd__decap_3
XFILLER_17_588 VGND VGND VPWR VPWR sky130_fd_sc_hd__decap_3
XFILLER_44_374 VGND VGND VPWR VPWR sky130_fd_sc_hd__decap_3
XFILLER_9_721 VGND VGND VPWR VPWR sky130_fd_sc_hd__decap_3
XFILLER_9_732 VGND VGND VPWR VPWR sky130_fd_sc_hd__decap_3
XTAP_TAPCELL_ROW_119_1817 VGND VPWR sky130_fd_sc_hd__tapvpwrvgnd_1
XFILLER_12_282 VGND VGND VPWR VPWR sky130_fd_sc_hd__decap_3
XFILLER_74_6 VGND VGND VPWR VPWR sky130_fd_sc_hd__decap_3
XFILLER_118_619 VGND VGND VPWR VPWR sky130_fd_sc_hd__decap_3
XFILLER_8_253 VGND VGND VPWR VPWR sky130_fd_sc_hd__decap_3
XFILLER_60_80 VGND VGND VPWR VPWR sky130_fd_sc_hd__decap_3
XFILLER_8_297 VGND VGND VPWR VPWR sky130_fd_sc_hd__decap_3
XFILLER_60_91 VGND VGND VPWR VPWR sky130_fd_sc_hd__decap_3
XPHY_EDGE_ROW_75_Right_75 VGND VGND VPWR VPWR sky130_fd_sc_hd__decap_3
XPHY_EDGE_ROW_97_Left_221 VGND VGND VPWR VPWR sky130_fd_sc_hd__decap_3
Xoutput506 _4528_/B VGND VGND VPWR VPWR instruction_out[24] sky130_fd_sc_hd__clkdlybuf4s25_1
Xoutput517 _5229_/B VGND VGND VPWR VPWR instruction_out[7] sky130_fd_sc_hd__clkdlybuf4s25_1
XTAP_TAPCELL_ROW_78_1282 VGND VPWR sky130_fd_sc_hd__tapvpwrvgnd_1
X_4330_ _5057_/B _4330_/B VGND VGND VPWR VPWR _4619_/B sky130_fd_sc_hd__or2_2
Xoutput528 _6994_/Q VGND VGND VPWR VPWR pc_out[17] sky130_fd_sc_hd__clkdlybuf4s25_1
Xoutput539 _7004_/Q VGND VGND VPWR VPWR pc_out[27] sky130_fd_sc_hd__clkdlybuf4s25_1
XFILLER_4_470 VGND VGND VPWR VPWR sky130_fd_sc_hd__decap_3
XFILLER_99_547 VGND VGND VPWR VPWR sky130_fd_sc_hd__decap_3
X_4261_ _7358_/Q _4261_/A2 _4348_/A2 _7166_/Q _4347_/C1 VGND VGND VPWR VPWR _4261_/X
+ sky130_fd_sc_hd__a221o_2
XFILLER_87_709 VGND VGND VPWR VPWR sky130_fd_sc_hd__decap_3
XFILLER_101_508 VGND VGND VPWR VPWR sky130_fd_sc_hd__decap_3
X_4192_ _4637_/B _4637_/C VGND VGND VPWR VPWR _4380_/A sky130_fd_sc_hd__and2_2
XFILLER_39_124 VGND VGND VPWR VPWR sky130_fd_sc_hd__decap_3
XFILLER_94_230 VGND VGND VPWR VPWR sky130_fd_sc_hd__decap_3
XFILLER_39_146 VGND VGND VPWR VPWR sky130_fd_sc_hd__decap_3
XFILLER_55_606 VGND VGND VPWR VPWR sky130_fd_sc_hd__decap_3
XFILLER_55_617 VGND VGND VPWR VPWR sky130_fd_sc_hd__decap_3
XFILLER_27_308 VGND VGND VPWR VPWR sky130_fd_sc_hd__decap_3
XFILLER_82_403 VGND VGND VPWR VPWR sky130_fd_sc_hd__decap_3
XFILLER_67_488 VGND VGND VPWR VPWR sky130_fd_sc_hd__decap_3
XFILLER_94_285 VGND VGND VPWR VPWR sky130_fd_sc_hd__decap_3
XPHY_EDGE_ROW_84_Right_84 VGND VGND VPWR VPWR sky130_fd_sc_hd__decap_3
XFILLER_82_436 VGND VGND VPWR VPWR sky130_fd_sc_hd__decap_3
X_6902_ _6960_/CLK _6902_/D VGND VGND VPWR VPWR _6902_/Q sky130_fd_sc_hd__dfxtp_2
XFILLER_82_458 VGND VGND VPWR VPWR sky130_fd_sc_hd__fill_2
XFILLER_82_469 VGND VGND VPWR VPWR sky130_fd_sc_hd__decap_3
XFILLER_63_650 VGND VGND VPWR VPWR sky130_fd_sc_hd__decap_3
XTAP_TAPCELL_ROW_46_870 VGND VPWR sky130_fd_sc_hd__tapvpwrvgnd_1
X_6833_ _6978_/CLK _6833_/D VGND VGND VPWR VPWR _6833_/Q sky130_fd_sc_hd__dfxtp_2
XFILLER_63_694 VGND VGND VPWR VPWR sky130_fd_sc_hd__decap_3
XFILLER_35_396 VGND VGND VPWR VPWR sky130_fd_sc_hd__decap_3
XFILLER_24_29 VGND VGND VPWR VPWR sky130_fd_sc_hd__fill_1
XFILLER_50_333 VGND VGND VPWR VPWR sky130_fd_sc_hd__decap_3
X_6764_ _6960_/CLK _6764_/D VGND VGND VPWR VPWR _6764_/Q sky130_fd_sc_hd__dfxtp_2
XFILLER_11_709 VGND VGND VPWR VPWR sky130_fd_sc_hd__decap_3
X_5715_ _7363_/Q hold913/X _5737_/S VGND VGND VPWR VPWR _6707_/D sky130_fd_sc_hd__mux2_2
X_6695_ _7378_/CLK _6695_/D VGND VGND VPWR VPWR _6695_/Q sky130_fd_sc_hd__dfxtp_2
XFILLER_31_591 VGND VGND VPWR VPWR sky130_fd_sc_hd__decap_3
X_5646_ _5646_/A VGND VGND VPWR VPWR _5646_/Y sky130_fd_sc_hd__inv_2
XFILLER_108_107 VGND VGND VPWR VPWR sky130_fd_sc_hd__decap_3
XPHY_EDGE_ROW_93_Right_93 VGND VGND VPWR VPWR sky130_fd_sc_hd__decap_3
X_5577_ _7040_/Q _5038_/X _5581_/S VGND VGND VPWR VPWR _7040_/D sky130_fd_sc_hd__mux2_2
XFILLER_117_641 VGND VGND VPWR VPWR sky130_fd_sc_hd__decap_3
X_7316_ _7318_/CLK _7316_/D _6596_/Y VGND VGND VPWR VPWR _7316_/Q sky130_fd_sc_hd__dfrtp_2
X_4528_ _4528_/A _4528_/B VGND VGND VPWR VPWR _7315_/D sky130_fd_sc_hd__or2_2
XFILLER_117_685 VGND VGND VPWR VPWR sky130_fd_sc_hd__decap_3
XFILLER_104_335 VGND VGND VPWR VPWR sky130_fd_sc_hd__decap_3
X_7247_ _7279_/CLK _7247_/D _6527_/Y VGND VGND VPWR VPWR _7247_/Q sky130_fd_sc_hd__dfrtp_2
X_4459_ _4040_/Y _4457_/X _4458_/X _4459_/C1 VGND VGND VPWR VPWR _5655_/B sky130_fd_sc_hd__o211a_2
XFILLER_49_37 VGND VGND VPWR VPWR sky130_fd_sc_hd__fill_1
XFILLER_77_208 VGND VGND VPWR VPWR sky130_fd_sc_hd__decap_3
XFILLER_104_368 VGND VGND VPWR VPWR sky130_fd_sc_hd__decap_3
X_7178_ _7372_/CLK _7178_/D _6458_/Y VGND VGND VPWR VPWR _7178_/Q sky130_fd_sc_hd__dfrtp_2
XFILLER_98_580 VGND VGND VPWR VPWR sky130_fd_sc_hd__decap_3
XFILLER_86_731 VGND VGND VPWR VPWR sky130_fd_sc_hd__decap_3
XFILLER_105_21 VGND VGND VPWR VPWR sky130_fd_sc_hd__decap_3
XFILLER_58_433 VGND VGND VPWR VPWR sky130_fd_sc_hd__decap_3
XFILLER_112_390 VGND VGND VPWR VPWR sky130_fd_sc_hd__decap_3
XFILLER_100_530 VGND VGND VPWR VPWR sky130_fd_sc_hd__fill_2
XFILLER_85_241 VGND VGND VPWR VPWR sky130_fd_sc_hd__decap_3
XFILLER_46_617 VGND VGND VPWR VPWR sky130_fd_sc_hd__decap_3
XFILLER_58_477 VGND VGND VPWR VPWR sky130_fd_sc_hd__fill_2
XFILLER_85_274 VGND VGND VPWR VPWR sky130_fd_sc_hd__decap_3
XFILLER_45_105 VGND VGND VPWR VPWR sky130_fd_sc_hd__decap_3
XFILLER_100_574 VGND VGND VPWR VPWR sky130_fd_sc_hd__decap_3
XFILLER_45_116 VGND VGND VPWR VPWR sky130_fd_sc_hd__fill_2
XFILLER_85_296 VGND VGND VPWR VPWR sky130_fd_sc_hd__decap_3
XFILLER_39_691 VGND VGND VPWR VPWR sky130_fd_sc_hd__decap_3
XFILLER_73_469 VGND VGND VPWR VPWR sky130_fd_sc_hd__fill_2
XTAP_TAPCELL_ROW_103_1607 VGND VPWR sky130_fd_sc_hd__tapvpwrvgnd_1
XFILLER_54_672 VGND VGND VPWR VPWR sky130_fd_sc_hd__decap_3
XFILLER_26_363 VGND VGND VPWR VPWR sky130_fd_sc_hd__fill_1
XFILLER_121_42 VGND VGND VPWR VPWR sky130_fd_sc_hd__decap_3
XFILLER_26_374 VGND VGND VPWR VPWR sky130_fd_sc_hd__decap_3
XFILLER_14_514 VGND VGND VPWR VPWR sky130_fd_sc_hd__fill_1
XFILLER_121_75 VGND VGND VPWR VPWR sky130_fd_sc_hd__decap_3
XFILLER_81_35 VGND VGND VPWR VPWR sky130_fd_sc_hd__decap_3
XFILLER_53_193 VGND VGND VPWR VPWR sky130_fd_sc_hd__decap_3
XFILLER_14_558 VGND VGND VPWR VPWR sky130_fd_sc_hd__decap_3
XFILLER_81_68 VGND VGND VPWR VPWR sky130_fd_sc_hd__decap_3
XFILLER_41_366 VGND VGND VPWR VPWR sky130_fd_sc_hd__fill_2
XTAP_TAPCELL_ROW_24_575 VGND VPWR sky130_fd_sc_hd__tapvpwrvgnd_1
XTAP_TAPCELL_ROW_62_1072 VGND VPWR sky130_fd_sc_hd__tapvpwrvgnd_1
XFILLER_10_731 VGND VGND VPWR VPWR sky130_fd_sc_hd__decap_3
XFILLER_6_713 VGND VGND VPWR VPWR sky130_fd_sc_hd__decap_3
XFILLER_5_234 VGND VGND VPWR VPWR sky130_fd_sc_hd__fill_2
XFILLER_108_663 VGND VGND VPWR VPWR sky130_fd_sc_hd__decap_3
XFILLER_107_140 VGND VGND VPWR VPWR sky130_fd_sc_hd__decap_3
XFILLER_5_267 VGND VGND VPWR VPWR sky130_fd_sc_hd__decap_3
XFILLER_123_611 VGND VGND VPWR VPWR sky130_fd_sc_hd__decap_3
XTAP_TAPCELL_ROW_114_1747 VGND VPWR sky130_fd_sc_hd__tapvpwrvgnd_1
XFILLER_108_696 VGND VGND VPWR VPWR sky130_fd_sc_hd__decap_3
XFILLER_30_94 VGND VGND VPWR VPWR sky130_fd_sc_hd__decap_3
XFILLER_107_184 VGND VGND VPWR VPWR sky130_fd_sc_hd__decap_3
XFILLER_69_709 VGND VGND VPWR VPWR sky130_fd_sc_hd__decap_3
XFILLER_96_528 VGND VGND VPWR VPWR sky130_fd_sc_hd__fill_1
XFILLER_110_305 VGND VGND VPWR VPWR sky130_fd_sc_hd__decap_3
XFILLER_89_591 VGND VGND VPWR VPWR sky130_fd_sc_hd__decap_3
XFILLER_103_390 VGND VGND VPWR VPWR sky130_fd_sc_hd__fill_2
XFILLER_92_701 VGND VGND VPWR VPWR sky130_fd_sc_hd__decap_3
XFILLER_37_606 VGND VGND VPWR VPWR sky130_fd_sc_hd__decap_3
XFILLER_37_617 VGND VGND VPWR VPWR sky130_fd_sc_hd__decap_3
XFILLER_92_734 VGND VGND VPWR VPWR sky130_fd_sc_hd__fill_1
XFILLER_76_285 VGND VGND VPWR VPWR sky130_fd_sc_hd__decap_3
XFILLER_91_222 VGND VGND VPWR VPWR sky130_fd_sc_hd__fill_2
XFILLER_64_447 VGND VGND VPWR VPWR sky130_fd_sc_hd__decap_3
XFILLER_64_469 VGND VGND VPWR VPWR sky130_fd_sc_hd__fill_2
XFILLER_17_330 VGND VGND VPWR VPWR sky130_fd_sc_hd__decap_3
XFILLER_91_255 VGND VGND VPWR VPWR sky130_fd_sc_hd__decap_3
XFILLER_45_650 VGND VGND VPWR VPWR sky130_fd_sc_hd__decap_3
XFILLER_17_352 VGND VGND VPWR VPWR sky130_fd_sc_hd__decap_3
XFILLER_32_300 VGND VGND VPWR VPWR sky130_fd_sc_hd__decap_3
XFILLER_45_694 VGND VGND VPWR VPWR sky130_fd_sc_hd__decap_3
XFILLER_17_385 VGND VGND VPWR VPWR sky130_fd_sc_hd__decap_3
XFILLER_60_631 VGND VGND VPWR VPWR sky130_fd_sc_hd__decap_3
X_3830_ _6860_/Q _3898_/B1 _3884_/B1 _6852_/Q _3829_/X VGND VGND VPWR VPWR _3830_/X
+ sky130_fd_sc_hd__a221o_2
XFILLER_60_675 VGND VGND VPWR VPWR sky130_fd_sc_hd__decap_3
XFILLER_13_591 VGND VGND VPWR VPWR sky130_fd_sc_hd__decap_3
XFILLER_9_573 VGND VGND VPWR VPWR sky130_fd_sc_hd__decap_3
X_6480_ _6544_/A VGND VGND VPWR VPWR _6480_/Y sky130_fd_sc_hd__inv_2
X_3692_ _6715_/Q _3767_/A2 _3759_/B1 _6893_/Q _3691_/X VGND VGND VPWR VPWR _3692_/X
+ sky130_fd_sc_hd__a221o_2
XFILLER_118_427 VGND VGND VPWR VPWR sky130_fd_sc_hd__decap_3
X_5362_ _3378_/A _5646_/A _5362_/C VGND VGND VPWR VPWR _5429_/S sky130_fd_sc_hd__and3b_2
XFILLER_99_311 VGND VGND VPWR VPWR sky130_fd_sc_hd__decap_3
XFILLER_114_622 VGND VGND VPWR VPWR sky130_fd_sc_hd__decap_3
X_7101_ _7356_/CLK _7101_/D _6381_/Y VGND VGND VPWR VPWR _7101_/Q sky130_fd_sc_hd__dfrtp_2
XFILLER_113_110 VGND VGND VPWR VPWR sky130_fd_sc_hd__fill_2
X_4313_ _4376_/A _4364_/A _4364_/B _4313_/D VGND VGND VPWR VPWR _4315_/A sky130_fd_sc_hd__or4_4
XFILLER_114_666 VGND VGND VPWR VPWR sky130_fd_sc_hd__decap_3
X_7032_ _7313_/CLK _7032_/D _6312_/Y VGND VGND VPWR VPWR _7032_/Q sky130_fd_sc_hd__dfrtp_2
XFILLER_99_388 VGND VGND VPWR VPWR sky130_fd_sc_hd__decap_3
X_4244_ _7293_/Q _4244_/B VGND VGND VPWR VPWR _4244_/X sky130_fd_sc_hd__and2_2
XFILLER_114_699 VGND VGND VPWR VPWR sky130_fd_sc_hd__fill_1
XFILLER_68_731 VGND VGND VPWR VPWR sky130_fd_sc_hd__decap_3
XFILLER_113_187 VGND VGND VPWR VPWR sky130_fd_sc_hd__fill_2
XFILLER_67_230 VGND VGND VPWR VPWR sky130_fd_sc_hd__decap_3
X_4175_ _7328_/Q _3964_/S _4347_/C1 _4174_/X VGND VGND VPWR VPWR _4175_/X sky130_fd_sc_hd__a211o_2
XFILLER_95_561 VGND VGND VPWR VPWR sky130_fd_sc_hd__decap_3
XFILLER_83_712 VGND VGND VPWR VPWR sky130_fd_sc_hd__decap_3
XFILLER_67_263 VGND VGND VPWR VPWR sky130_fd_sc_hd__decap_3
XFILLER_28_628 VGND VGND VPWR VPWR sky130_fd_sc_hd__decap_3
XFILLER_82_200 VGND VGND VPWR VPWR sky130_fd_sc_hd__decap_3
XFILLER_55_414 VGND VGND VPWR VPWR sky130_fd_sc_hd__decap_3
XFILLER_95_594 VGND VGND VPWR VPWR sky130_fd_sc_hd__decap_3
XFILLER_27_116 VGND VGND VPWR VPWR sky130_fd_sc_hd__decap_3
XFILLER_82_277 VGND VGND VPWR VPWR sky130_fd_sc_hd__decap_3
XFILLER_36_672 VGND VGND VPWR VPWR sky130_fd_sc_hd__decap_3
XFILLER_82_299 VGND VGND VPWR VPWR sky130_fd_sc_hd__decap_3
XFILLER_51_620 VGND VGND VPWR VPWR sky130_fd_sc_hd__decap_3
XFILLER_23_311 VGND VGND VPWR VPWR sky130_fd_sc_hd__decap_3
XFILLER_63_491 VGND VGND VPWR VPWR sky130_fd_sc_hd__decap_3
X_6816_ clkload8/A _6816_/D VGND VGND VPWR VPWR _6816_/Q sky130_fd_sc_hd__dfxtp_2
XFILLER_51_653 VGND VGND VPWR VPWR sky130_fd_sc_hd__decap_3
XFILLER_50_130 VGND VGND VPWR VPWR sky130_fd_sc_hd__fill_2
XFILLER_50_141 VGND VGND VPWR VPWR sky130_fd_sc_hd__decap_3
XFILLER_51_697 VGND VGND VPWR VPWR sky130_fd_sc_hd__decap_3
X_6747_ clkload4/A _6747_/D VGND VGND VPWR VPWR _6747_/Q sky130_fd_sc_hd__dfxtp_2
XFILLER_23_399 VGND VGND VPWR VPWR sky130_fd_sc_hd__decap_3
XTAP_TAPCELL_ROW_21_534 VGND VPWR sky130_fd_sc_hd__tapvpwrvgnd_1
XTAP_TAPCELL_ROW_21_545 VGND VPWR sky130_fd_sc_hd__tapvpwrvgnd_1
XFILLER_109_405 VGND VGND VPWR VPWR sky130_fd_sc_hd__decap_3
X_6678_ _6678_/A VGND VGND VPWR VPWR _6678_/Y sky130_fd_sc_hd__inv_2
XFILLER_109_438 VGND VGND VPWR VPWR sky130_fd_sc_hd__fill_2
XFILLER_109_449 VGND VGND VPWR VPWR sky130_fd_sc_hd__fill_2
XFILLER_105_600 VGND VGND VPWR VPWR sky130_fd_sc_hd__decap_3
XFILLER_3_727 VGND VGND VPWR VPWR sky130_fd_sc_hd__fill_1
XFILLER_2_215 VGND VGND VPWR VPWR sky130_fd_sc_hd__decap_3
XFILLER_117_482 VGND VGND VPWR VPWR sky130_fd_sc_hd__decap_3
XFILLER_105_644 VGND VGND VPWR VPWR sky130_fd_sc_hd__decap_3
XFILLER_116_20 VGND VGND VPWR VPWR sky130_fd_sc_hd__decap_3
XFILLER_78_528 VGND VGND VPWR VPWR sky130_fd_sc_hd__decap_3
XFILLER_105_688 VGND VGND VPWR VPWR sky130_fd_sc_hd__decap_3
XFILLER_120_625 VGND VGND VPWR VPWR sky130_fd_sc_hd__decap_3
XFILLER_116_53 VGND VGND VPWR VPWR sky130_fd_sc_hd__decap_3
XFILLER_104_187 VGND VGND VPWR VPWR sky130_fd_sc_hd__decap_3
XFILLER_120_669 VGND VGND VPWR VPWR sky130_fd_sc_hd__decap_3
XFILLER_116_97 VGND VGND VPWR VPWR sky130_fd_sc_hd__decap_3
XFILLER_19_606 VGND VGND VPWR VPWR sky130_fd_sc_hd__decap_3
XFILLER_76_68 VGND VGND VPWR VPWR sky130_fd_sc_hd__decap_3
XFILLER_74_701 VGND VGND VPWR VPWR sky130_fd_sc_hd__decap_3
XFILLER_19_617 VGND VGND VPWR VPWR sky130_fd_sc_hd__decap_3
XFILLER_58_263 VGND VGND VPWR VPWR sky130_fd_sc_hd__decap_3
XFILLER_86_583 VGND VGND VPWR VPWR sky130_fd_sc_hd__decap_3
XFILLER_73_200 VGND VGND VPWR VPWR sky130_fd_sc_hd__decap_3
XFILLER_74_734 VGND VGND VPWR VPWR sky130_fd_sc_hd__fill_1
XFILLER_100_371 VGND VGND VPWR VPWR sky130_fd_sc_hd__fill_1
XTAP_TAPCELL_ROW_29_645 VGND VPWR sky130_fd_sc_hd__tapvpwrvgnd_1
XFILLER_18_149 VGND VGND VPWR VPWR sky130_fd_sc_hd__decap_3
XFILLER_73_255 VGND VGND VPWR VPWR sky130_fd_sc_hd__decap_3
XFILLER_61_406 VGND VGND VPWR VPWR sky130_fd_sc_hd__decap_3
XFILLER_27_650 VGND VGND VPWR VPWR sky130_fd_sc_hd__decap_3
XTAP_TAPCELL_ROW_64_1101 VGND VPWR sky130_fd_sc_hd__tapvpwrvgnd_1
XTAP_TAPCELL_ROW_1_281 VGND VPWR sky130_fd_sc_hd__tapvpwrvgnd_1
XFILLER_73_299 VGND VGND VPWR VPWR sky130_fd_sc_hd__decap_3
XFILLER_61_439 VGND VGND VPWR VPWR sky130_fd_sc_hd__decap_3
XFILLER_27_694 VGND VGND VPWR VPWR sky130_fd_sc_hd__decap_3
XFILLER_42_631 VGND VGND VPWR VPWR sky130_fd_sc_hd__decap_3
XFILLER_42_675 VGND VGND VPWR VPWR sky130_fd_sc_hd__decap_3
XFILLER_25_83 VGND VGND VPWR VPWR sky130_fd_sc_hd__decap_3
XFILLER_41_163 VGND VGND VPWR VPWR sky130_fd_sc_hd__decap_3
XFILLER_14_377 VGND VGND VPWR VPWR sky130_fd_sc_hd__decap_3
XFILLER_10_572 VGND VGND VPWR VPWR sky130_fd_sc_hd__decap_3
XFILLER_6_554 VGND VGND VPWR VPWR sky130_fd_sc_hd__decap_3
XFILLER_6_587 VGND VGND VPWR VPWR sky130_fd_sc_hd__fill_1
XFILLER_6_598 VGND VGND VPWR VPWR sky130_fd_sc_hd__decap_3
XTAP_TAPCELL_ROW_75_1241 VGND VPWR sky130_fd_sc_hd__tapvpwrvgnd_1
XFILLER_123_452 VGND VGND VPWR VPWR sky130_fd_sc_hd__fill_1
XFILLER_111_603 VGND VGND VPWR VPWR sky130_fd_sc_hd__decap_3
XTAP_TAPCELL_ROW_9_381 VGND VPWR sky130_fd_sc_hd__tapvpwrvgnd_1
XFILLER_37_6 VGND VGND VPWR VPWR sky130_fd_sc_hd__decap_3
XFILLER_123_485 VGND VGND VPWR VPWR sky130_fd_sc_hd__decap_3
XFILLER_110_102 VGND VGND VPWR VPWR sky130_fd_sc_hd__fill_2
XFILLER_111_647 VGND VGND VPWR VPWR sky130_fd_sc_hd__decap_3
XFILLER_96_347 VGND VGND VPWR VPWR sky130_fd_sc_hd__decap_3
XFILLER_2_21 VGND VGND VPWR VPWR sky130_fd_sc_hd__decap_3
XFILLER_1_281 VGND VGND VPWR VPWR sky130_fd_sc_hd__decap_3
XFILLER_2_32 VGND VGND VPWR VPWR sky130_fd_sc_hd__decap_3
XFILLER_77_561 VGND VGND VPWR VPWR sky130_fd_sc_hd__fill_1
XFILLER_49_252 VGND VGND VPWR VPWR sky130_fd_sc_hd__decap_3
XFILLER_65_712 VGND VGND VPWR VPWR sky130_fd_sc_hd__decap_3
XFILLER_64_200 VGND VGND VPWR VPWR sky130_fd_sc_hd__decap_3
XFILLER_77_594 VGND VGND VPWR VPWR sky130_fd_sc_hd__decap_3
XFILLER_37_425 VGND VGND VPWR VPWR sky130_fd_sc_hd__decap_3
XFILLER_49_296 VGND VGND VPWR VPWR sky130_fd_sc_hd__decap_3
XFILLER_64_233 VGND VGND VPWR VPWR sky130_fd_sc_hd__decap_3
XFILLER_37_447 VGND VGND VPWR VPWR sky130_fd_sc_hd__fill_1
XFILLER_92_553 VGND VGND VPWR VPWR sky130_fd_sc_hd__decap_3
XFILLER_25_609 VGND VGND VPWR VPWR sky130_fd_sc_hd__decap_3
XFILLER_80_704 VGND VGND VPWR VPWR sky130_fd_sc_hd__decap_3
XFILLER_92_586 VGND VGND VPWR VPWR sky130_fd_sc_hd__fill_2
XFILLER_64_277 VGND VGND VPWR VPWR sky130_fd_sc_hd__decap_3
XFILLER_18_672 VGND VGND VPWR VPWR sky130_fd_sc_hd__decap_3
X_4931_ _4931_/A _4931_/B VGND VGND VPWR VPWR _6996_/D sky130_fd_sc_hd__nor2_2
XTAP_TAPCELL_ROW_86_1381 VGND VPWR sky130_fd_sc_hd__tapvpwrvgnd_1
XFILLER_33_620 VGND VGND VPWR VPWR sky130_fd_sc_hd__decap_3
XFILLER_33_653 VGND VGND VPWR VPWR sky130_fd_sc_hd__decap_3
X_4862_ _4825_/B _4862_/B VGND VGND VPWR VPWR _7000_/D sky130_fd_sc_hd__and2b_2
XFILLER_32_141 VGND VGND VPWR VPWR sky130_fd_sc_hd__decap_3
XFILLER_32_152 VGND VGND VPWR VPWR sky130_fd_sc_hd__decap_3
X_6601_ _6640_/A VGND VGND VPWR VPWR _6601_/Y sky130_fd_sc_hd__inv_2
XFILLER_60_472 VGND VGND VPWR VPWR sky130_fd_sc_hd__decap_3
X_3813_ _3802_/X _3812_/X _3991_/A VGND VGND VPWR VPWR _3813_/Y sky130_fd_sc_hd__o21ai_2
XFILLER_33_697 VGND VGND VPWR VPWR sky130_fd_sc_hd__decap_3
XANTENNA_15 _4961_/A VGND VGND VPWR VPWR sky130_fd_sc_hd__diode_2
XPHY_EDGE_ROW_25_Left_149 VGND VGND VPWR VPWR sky130_fd_sc_hd__decap_3
X_4793_ hold995/X _4792_/X _4837_/S VGND VGND VPWR VPWR _7274_/D sky130_fd_sc_hd__mux2_2
XFILLER_119_703 VGND VGND VPWR VPWR sky130_fd_sc_hd__decap_3
X_6532_ _6630_/A VGND VGND VPWR VPWR _6532_/Y sky130_fd_sc_hd__inv_2
X_3744_ _6728_/Q _3892_/A2 _3656_/Y _6973_/Q VGND VGND VPWR VPWR _3744_/X sky130_fd_sc_hd__a22o_2
XFILLER_9_381 VGND VGND VPWR VPWR sky130_fd_sc_hd__decap_3
XFILLER_118_224 VGND VGND VPWR VPWR sky130_fd_sc_hd__decap_3
X_6463_ _6660_/A VGND VGND VPWR VPWR _6463_/Y sky130_fd_sc_hd__inv_2
X_6394_ _6618_/A VGND VGND VPWR VPWR _6394_/Y sky130_fd_sc_hd__inv_2
XFILLER_114_452 VGND VGND VPWR VPWR sky130_fd_sc_hd__decap_3
XFILLER_99_163 VGND VGND VPWR VPWR sky130_fd_sc_hd__decap_3
XFILLER_102_625 VGND VGND VPWR VPWR sky130_fd_sc_hd__decap_3
X_5276_ hold997/X _5094_/X _5278_/S VGND VGND VPWR VPWR _7192_/D sky130_fd_sc_hd__mux2_2
XPHY_EDGE_ROW_34_Left_158 VGND VGND VPWR VPWR sky130_fd_sc_hd__decap_3
XFILLER_99_196 VGND VGND VPWR VPWR sky130_fd_sc_hd__decap_3
XFILLER_101_113 VGND VGND VPWR VPWR sky130_fd_sc_hd__decap_3
X_7015_ _7313_/CLK _7015_/D _6295_/Y VGND VGND VPWR VPWR _7015_/Q sky130_fd_sc_hd__dfrtp_2
X_4227_ _7355_/Q _4270_/B _4352_/B1 _7163_/Q VGND VGND VPWR VPWR _4227_/X sky130_fd_sc_hd__a22o_2
XFILLER_102_669 VGND VGND VPWR VPWR sky130_fd_sc_hd__decap_3
XFILLER_56_701 VGND VGND VPWR VPWR sky130_fd_sc_hd__decap_3
XFILLER_55_200 VGND VGND VPWR VPWR sky130_fd_sc_hd__fill_1
X_4158_ _4158_/A _4158_/B VGND VGND VPWR VPWR _4920_/A sky130_fd_sc_hd__nand2_2
XFILLER_56_734 VGND VGND VPWR VPWR sky130_fd_sc_hd__fill_1
XFILLER_55_211 VGND VGND VPWR VPWR sky130_fd_sc_hd__decap_3
XFILLER_83_542 VGND VGND VPWR VPWR sky130_fd_sc_hd__decap_3
XFILLER_83_564 VGND VGND VPWR VPWR sky130_fd_sc_hd__decap_3
X_4089_ _7206_/Q _3956_/S _4419_/B1 _7398_/Q VGND VGND VPWR VPWR _4089_/X sky130_fd_sc_hd__a22o_2
XFILLER_71_715 VGND VGND VPWR VPWR sky130_fd_sc_hd__decap_3
XTAP_TAPCELL_ROW_26_604 VGND VPWR sky130_fd_sc_hd__tapvpwrvgnd_1
XFILLER_43_417 VGND VGND VPWR VPWR sky130_fd_sc_hd__decap_3
XFILLER_102_11 VGND VGND VPWR VPWR sky130_fd_sc_hd__decap_3
XFILLER_83_597 VGND VGND VPWR VPWR sky130_fd_sc_hd__decap_3
XFILLER_70_236 VGND VGND VPWR VPWR sky130_fd_sc_hd__decap_3
XFILLER_36_480 VGND VGND VPWR VPWR sky130_fd_sc_hd__decap_3
XFILLER_24_631 VGND VGND VPWR VPWR sky130_fd_sc_hd__decap_3
XTAP_TAPCELL_ROW_54_968 VGND VPWR sky130_fd_sc_hd__tapvpwrvgnd_1
XFILLER_70_247 VGND VGND VPWR VPWR sky130_fd_sc_hd__decap_3
XFILLER_62_26 VGND VGND VPWR VPWR sky130_fd_sc_hd__fill_2
XFILLER_70_269 VGND VGND VPWR VPWR sky130_fd_sc_hd__decap_3
XFILLER_62_37 VGND VGND VPWR VPWR sky130_fd_sc_hd__fill_1
XFILLER_24_675 VGND VGND VPWR VPWR sky130_fd_sc_hd__decap_3
XPHY_EDGE_ROW_43_Left_167 VGND VGND VPWR VPWR sky130_fd_sc_hd__decap_3
XFILLER_23_152 VGND VGND VPWR VPWR sky130_fd_sc_hd__decap_3
XFILLER_11_325 VGND VGND VPWR VPWR sky130_fd_sc_hd__fill_1
XFILLER_7_329 VGND VGND VPWR VPWR sky130_fd_sc_hd__decap_3
XFILLER_109_213 VGND VGND VPWR VPWR sky130_fd_sc_hd__fill_2
XFILLER_11_52 VGND VGND VPWR VPWR sky130_fd_sc_hd__decap_3
XFILLER_3_535 VGND VGND VPWR VPWR sky130_fd_sc_hd__decap_3
XFILLER_11_85 VGND VGND VPWR VPWR sky130_fd_sc_hd__decap_3
XFILLER_117_290 VGND VGND VPWR VPWR sky130_fd_sc_hd__decap_3
XTAP_TAPCELL_ROW_111_1706 VGND VPWR sky130_fd_sc_hd__tapvpwrvgnd_1
XFILLER_87_12 VGND VGND VPWR VPWR sky130_fd_sc_hd__decap_3
XFILLER_2_3 VGND VGND VPWR VPWR sky130_fd_sc_hd__decap_3
XPHY_EDGE_ROW_52_Left_176 VGND VGND VPWR VPWR sky130_fd_sc_hd__decap_3
XFILLER_3_579 VGND VGND VPWR VPWR sky130_fd_sc_hd__decap_3
XFILLER_105_463 VGND VGND VPWR VPWR sky130_fd_sc_hd__decap_3
XFILLER_87_45 VGND VGND VPWR VPWR sky130_fd_sc_hd__decap_3
XFILLER_87_67 VGND VGND VPWR VPWR sky130_fd_sc_hd__decap_3
XTAP_TAPCELL_ROW_6_340 VGND VPWR sky130_fd_sc_hd__tapvpwrvgnd_1
XTAP_TAPCELL_ROW_6_351 VGND VPWR sky130_fd_sc_hd__tapvpwrvgnd_1
XFILLER_93_306 VGND VGND VPWR VPWR sky130_fd_sc_hd__decap_3
XFILLER_120_466 VGND VGND VPWR VPWR sky130_fd_sc_hd__decap_3
XTAP_TAPCELL_ROW_70_1171 VGND VPWR sky130_fd_sc_hd__tapvpwrvgnd_1
XFILLER_120_477 VGND VGND VPWR VPWR sky130_fd_sc_hd__decap_3
XTAP_TAPCELL_ROW_70_1182 VGND VPWR sky130_fd_sc_hd__tapvpwrvgnd_1
XFILLER_47_712 VGND VGND VPWR VPWR sky130_fd_sc_hd__decap_3
XFILLER_19_414 VGND VGND VPWR VPWR sky130_fd_sc_hd__decap_3
XFILLER_101_691 VGND VGND VPWR VPWR sky130_fd_sc_hd__decap_3
XFILLER_46_222 VGND VGND VPWR VPWR sky130_fd_sc_hd__decap_3
XFILLER_19_447 VGND VGND VPWR VPWR sky130_fd_sc_hd__fill_1
XFILLER_62_704 VGND VGND VPWR VPWR sky130_fd_sc_hd__decap_3
XFILLER_19_469 VGND VGND VPWR VPWR sky130_fd_sc_hd__decap_3
XTAP_TAPCELL_ROW_109_1679 VGND VPWR sky130_fd_sc_hd__tapvpwrvgnd_1
XFILLER_74_586 VGND VGND VPWR VPWR sky130_fd_sc_hd__fill_2
XFILLER_61_203 VGND VGND VPWR VPWR sky130_fd_sc_hd__decap_3
XFILLER_46_277 VGND VGND VPWR VPWR sky130_fd_sc_hd__decap_3
XFILLER_61_225 VGND VGND VPWR VPWR sky130_fd_sc_hd__decap_3
XFILLER_34_439 VGND VGND VPWR VPWR sky130_fd_sc_hd__decap_3
XFILLER_15_620 VGND VGND VPWR VPWR sky130_fd_sc_hd__decap_3
XPHY_EDGE_ROW_61_Left_185 VGND VGND VPWR VPWR sky130_fd_sc_hd__decap_3
XFILLER_27_491 VGND VGND VPWR VPWR sky130_fd_sc_hd__decap_3
XFILLER_15_653 VGND VGND VPWR VPWR sky130_fd_sc_hd__decap_3
XTAP_TAPCELL_ROW_122_1857 VGND VPWR sky130_fd_sc_hd__tapvpwrvgnd_1
XFILLER_30_601 VGND VGND VPWR VPWR sky130_fd_sc_hd__decap_3
XFILLER_15_697 VGND VGND VPWR VPWR sky130_fd_sc_hd__decap_3
XFILLER_42_483 VGND VGND VPWR VPWR sky130_fd_sc_hd__fill_1
XFILLER_30_634 VGND VGND VPWR VPWR sky130_fd_sc_hd__decap_3
XFILLER_14_185 VGND VGND VPWR VPWR sky130_fd_sc_hd__fill_2
XFILLER_30_645 VGND VGND VPWR VPWR sky130_fd_sc_hd__decap_3
XFILLER_30_678 VGND VGND VPWR VPWR sky130_fd_sc_hd__decap_3
Xhold808 _6818_/Q VGND VGND VPWR VPWR _6818_/D sky130_fd_sc_hd__dlygate4sd3_1
XFILLER_116_728 VGND VGND VPWR VPWR sky130_fd_sc_hd__decap_3
Xhold819 _6719_/Q VGND VGND VPWR VPWR _6719_/D sky130_fd_sc_hd__dlygate4sd3_1
X_3460_ _7313_/Q _3989_/S _4346_/B1 _7345_/Q _4248_/A VGND VGND VPWR VPWR _3460_/X
+ sky130_fd_sc_hd__a221o_2
XPHY_EDGE_ROW_70_Left_194 VGND VGND VPWR VPWR sky130_fd_sc_hd__decap_3
X_3391_ _7251_/Q _3358_/X _3390_/X VGND VGND VPWR VPWR _3589_/A sky130_fd_sc_hd__a21oi_2
XFILLER_97_612 VGND VGND VPWR VPWR sky130_fd_sc_hd__decap_3
XFILLER_69_303 VGND VGND VPWR VPWR sky130_fd_sc_hd__decap_3
X_5130_ _5130_/A _5670_/B _5130_/C VGND VGND VPWR VPWR _6982_/D sky130_fd_sc_hd__nor3_2
XFILLER_97_623 VGND VGND VPWR VPWR sky130_fd_sc_hd__decap_3
XFILLER_97_656 VGND VGND VPWR VPWR sky130_fd_sc_hd__decap_3
XFILLER_123_293 VGND VGND VPWR VPWR sky130_fd_sc_hd__decap_3
XFILLER_111_433 VGND VGND VPWR VPWR sky130_fd_sc_hd__decap_3
XFILLER_96_144 VGND VGND VPWR VPWR sky130_fd_sc_hd__decap_3
X_5061_ _6988_/D _5060_/X _5156_/S VGND VGND VPWR VPWR _5061_/X sky130_fd_sc_hd__mux2_2
XFILLER_69_369 VGND VGND VPWR VPWR sky130_fd_sc_hd__decap_3
XFILLER_84_306 VGND VGND VPWR VPWR sky130_fd_sc_hd__fill_2
XFILLER_38_701 VGND VGND VPWR VPWR sky130_fd_sc_hd__decap_3
XTAP_TAPCELL_ROW_88_1410 VGND VPWR sky130_fd_sc_hd__tapvpwrvgnd_1
XFILLER_38_734 VGND VGND VPWR VPWR sky130_fd_sc_hd__fill_1
XFILLER_37_200 VGND VGND VPWR VPWR sky130_fd_sc_hd__fill_1
XFILLER_65_520 VGND VGND VPWR VPWR sky130_fd_sc_hd__decap_3
XFILLER_65_542 VGND VGND VPWR VPWR sky130_fd_sc_hd__decap_3
XFILLER_37_255 VGND VGND VPWR VPWR sky130_fd_sc_hd__decap_3
XFILLER_92_361 VGND VGND VPWR VPWR sky130_fd_sc_hd__decap_3
XFILLER_53_715 VGND VGND VPWR VPWR sky130_fd_sc_hd__decap_3
XFILLER_65_586 VGND VGND VPWR VPWR sky130_fd_sc_hd__decap_3
XFILLER_37_277 VGND VGND VPWR VPWR sky130_fd_sc_hd__decap_3
XFILLER_25_439 VGND VGND VPWR VPWR sky130_fd_sc_hd__decap_3
XFILLER_37_299 VGND VGND VPWR VPWR sky130_fd_sc_hd__fill_1
XFILLER_18_480 VGND VGND VPWR VPWR sky130_fd_sc_hd__decap_3
X_4914_ hold994/X _4913_/X _4914_/S VGND VGND VPWR VPWR _7267_/D sky130_fd_sc_hd__mux2_2
XFILLER_40_409 VGND VGND VPWR VPWR sky130_fd_sc_hd__decap_3
XFILLER_52_269 VGND VGND VPWR VPWR sky130_fd_sc_hd__decap_3
XFILLER_80_589 VGND VGND VPWR VPWR sky130_fd_sc_hd__decap_3
XFILLER_33_461 VGND VGND VPWR VPWR sky130_fd_sc_hd__decap_3
XFILLER_21_601 VGND VGND VPWR VPWR sky130_fd_sc_hd__decap_3
XTAP_TAPCELL_ROW_51_927 VGND VPWR sky130_fd_sc_hd__tapvpwrvgnd_1
XFILLER_21_623 VGND VGND VPWR VPWR sky130_fd_sc_hd__decap_3
X_4845_ _4845_/A VGND VGND VPWR VPWR _4872_/A sky130_fd_sc_hd__inv_2
XFILLER_60_280 VGND VGND VPWR VPWR sky130_fd_sc_hd__decap_3
XFILLER_32_29 VGND VGND VPWR VPWR sky130_fd_sc_hd__fill_1
XFILLER_21_656 VGND VGND VPWR VPWR sky130_fd_sc_hd__decap_3
XFILLER_20_144 VGND VGND VPWR VPWR sky130_fd_sc_hd__decap_3
XFILLER_119_511 VGND VGND VPWR VPWR sky130_fd_sc_hd__decap_3
X_4776_ _7004_/Q _4804_/A VGND VGND VPWR VPWR _4777_/C sky130_fd_sc_hd__or2_2
XTAP_TAPCELL_ROW_31_673 VGND VPWR sky130_fd_sc_hd__tapvpwrvgnd_1
XTAP_TAPCELL_ROW_99_1550 VGND VPWR sky130_fd_sc_hd__tapvpwrvgnd_1
X_6515_ _6613_/A VGND VGND VPWR VPWR _6515_/Y sky130_fd_sc_hd__inv_2
XFILLER_119_544 VGND VGND VPWR VPWR sky130_fd_sc_hd__decap_3
X_3727_ _3746_/B _3733_/C VGND VGND VPWR VPWR _3728_/B sky130_fd_sc_hd__nand2_2
XFILLER_107_706 VGND VGND VPWR VPWR sky130_fd_sc_hd__decap_3
XFILLER_119_588 VGND VGND VPWR VPWR sky130_fd_sc_hd__decap_3
X_6446_ _6544_/A VGND VGND VPWR VPWR _6446_/Y sky130_fd_sc_hd__inv_2
XFILLER_106_9 VGND VGND VPWR VPWR sky130_fd_sc_hd__decap_3
XFILLER_106_249 VGND VGND VPWR VPWR sky130_fd_sc_hd__decap_3
X_6377_ _6608_/A VGND VGND VPWR VPWR _6377_/Y sky130_fd_sc_hd__inv_2
X_3589_ _3589_/A _3589_/B VGND VGND VPWR VPWR _3590_/B sky130_fd_sc_hd__nor2_2
XFILLER_88_601 VGND VGND VPWR VPWR sky130_fd_sc_hd__decap_3
XFILLER_0_516 VGND VGND VPWR VPWR sky130_fd_sc_hd__decap_3
XFILLER_87_100 VGND VGND VPWR VPWR sky130_fd_sc_hd__decap_3
XFILLER_88_634 VGND VGND VPWR VPWR sky130_fd_sc_hd__decap_3
XFILLER_88_645 VGND VGND VPWR VPWR sky130_fd_sc_hd__decap_3
XFILLER_87_122 VGND VGND VPWR VPWR sky130_fd_sc_hd__decap_3
XFILLER_88_678 VGND VGND VPWR VPWR sky130_fd_sc_hd__decap_3
XFILLER_102_455 VGND VGND VPWR VPWR sky130_fd_sc_hd__decap_3
XFILLER_87_155 VGND VGND VPWR VPWR sky130_fd_sc_hd__decap_3
XFILLER_75_317 VGND VGND VPWR VPWR sky130_fd_sc_hd__fill_2
XFILLER_29_712 VGND VGND VPWR VPWR sky130_fd_sc_hd__decap_3
XFILLER_102_477 VGND VGND VPWR VPWR sky130_fd_sc_hd__decap_3
XTAP_TAPCELL_ROW_3_310 VGND VPWR sky130_fd_sc_hd__tapvpwrvgnd_1
XFILLER_87_188 VGND VGND VPWR VPWR sky130_fd_sc_hd__decap_3
XFILLER_28_200 VGND VGND VPWR VPWR sky130_fd_sc_hd__decap_3
XFILLER_113_21 VGND VGND VPWR VPWR sky130_fd_sc_hd__decap_3
XFILLER_28_233 VGND VGND VPWR VPWR sky130_fd_sc_hd__decap_3
XFILLER_44_704 VGND VGND VPWR VPWR sky130_fd_sc_hd__decap_3
XFILLER_113_54 VGND VGND VPWR VPWR sky130_fd_sc_hd__fill_2
XTAP_TAPCELL_ROW_39_773 VGND VPWR sky130_fd_sc_hd__tapvpwrvgnd_1
XFILLER_28_277 VGND VGND VPWR VPWR sky130_fd_sc_hd__decap_3
XFILLER_113_87 VGND VGND VPWR VPWR sky130_fd_sc_hd__decap_3
XFILLER_71_534 VGND VGND VPWR VPWR sky130_fd_sc_hd__fill_2
XFILLER_43_225 VGND VGND VPWR VPWR sky130_fd_sc_hd__decap_3
XFILLER_71_545 VGND VGND VPWR VPWR sky130_fd_sc_hd__decap_3
XFILLER_71_567 VGND VGND VPWR VPWR sky130_fd_sc_hd__fill_2
XFILLER_43_258 VGND VGND VPWR VPWR sky130_fd_sc_hd__fill_1
XFILLER_43_269 VGND VGND VPWR VPWR sky130_fd_sc_hd__decap_3
XFILLER_31_409 VGND VGND VPWR VPWR sky130_fd_sc_hd__decap_3
XFILLER_71_589 VGND VGND VPWR VPWR sky130_fd_sc_hd__decap_3
XFILLER_12_601 VGND VGND VPWR VPWR sky130_fd_sc_hd__decap_3
XFILLER_11_100 VGND VGND VPWR VPWR sky130_fd_sc_hd__decap_3
XFILLER_12_634 VGND VGND VPWR VPWR sky130_fd_sc_hd__decap_3
XFILLER_12_645 VGND VGND VPWR VPWR sky130_fd_sc_hd__decap_3
XFILLER_8_616 VGND VGND VPWR VPWR sky130_fd_sc_hd__decap_3
XFILLER_12_678 VGND VGND VPWR VPWR sky130_fd_sc_hd__decap_3
XFILLER_22_51 VGND VGND VPWR VPWR sky130_fd_sc_hd__decap_3
XTAP_TAPCELL_ROW_59_1033 VGND VPWR sky130_fd_sc_hd__tapvpwrvgnd_1
XFILLER_3_332 VGND VGND VPWR VPWR sky130_fd_sc_hd__decap_3
XFILLER_113_709 VGND VGND VPWR VPWR sky130_fd_sc_hd__decap_3
XTAP_TAPCELL_ROW_72_1200 VGND VPWR sky130_fd_sc_hd__tapvpwrvgnd_1
XFILLER_79_612 VGND VGND VPWR VPWR sky130_fd_sc_hd__decap_3
XFILLER_79_623 VGND VGND VPWR VPWR sky130_fd_sc_hd__decap_3
XFILLER_78_100 VGND VGND VPWR VPWR sky130_fd_sc_hd__decap_3
XFILLER_3_376 VGND VGND VPWR VPWR sky130_fd_sc_hd__decap_3
XFILLER_79_656 VGND VGND VPWR VPWR sky130_fd_sc_hd__decap_3
XFILLER_78_133 VGND VGND VPWR VPWR sky130_fd_sc_hd__decap_3
XFILLER_78_144 VGND VGND VPWR VPWR sky130_fd_sc_hd__decap_3
XFILLER_94_604 VGND VGND VPWR VPWR sky130_fd_sc_hd__decap_3
XFILLER_78_177 VGND VGND VPWR VPWR sky130_fd_sc_hd__decap_3
XFILLER_94_637 VGND VGND VPWR VPWR sky130_fd_sc_hd__decap_3
XFILLER_19_200 VGND VGND VPWR VPWR sky130_fd_sc_hd__decap_3
XFILLER_94_648 VGND VGND VPWR VPWR sky130_fd_sc_hd__decap_3
XFILLER_120_285 VGND VGND VPWR VPWR sky130_fd_sc_hd__decap_3
XFILLER_47_564 VGND VGND VPWR VPWR sky130_fd_sc_hd__decap_3
XFILLER_35_715 VGND VGND VPWR VPWR sky130_fd_sc_hd__decap_3
XFILLER_62_501 VGND VGND VPWR VPWR sky130_fd_sc_hd__decap_3
XFILLER_74_383 VGND VGND VPWR VPWR sky130_fd_sc_hd__fill_2
XFILLER_34_225 VGND VGND VPWR VPWR sky130_fd_sc_hd__decap_3
XFILLER_50_707 VGND VGND VPWR VPWR sky130_fd_sc_hd__decap_3
XTAP_TAPCELL_ROW_83_1340 VGND VPWR sky130_fd_sc_hd__tapvpwrvgnd_1
XTAP_TAPCELL_ROW_83_1351 VGND VPWR sky130_fd_sc_hd__tapvpwrvgnd_1
XFILLER_62_589 VGND VGND VPWR VPWR sky130_fd_sc_hd__decap_3
XTAP_TAPCELL_ROW_17_489 VGND VPWR sky130_fd_sc_hd__tapvpwrvgnd_1
XFILLER_42_291 VGND VGND VPWR VPWR sky130_fd_sc_hd__decap_3
X_4630_ _4627_/Y _4629_/Y _4372_/A VGND VGND VPWR VPWR _4630_/X sky130_fd_sc_hd__a21o_2
XFILLER_30_464 VGND VGND VPWR VPWR sky130_fd_sc_hd__decap_3
XFILLER_8_75 VGND VGND VPWR VPWR sky130_fd_sc_hd__fill_1
X_4561_ _4561_/A _4577_/B VGND VGND VPWR VPWR _7300_/D sky130_fd_sc_hd__and2_2
XFILLER_8_97 VGND VGND VPWR VPWR sky130_fd_sc_hd__decap_3
XFILLER_116_503 VGND VGND VPWR VPWR sky130_fd_sc_hd__decap_3
X_6300_ _6618_/A VGND VGND VPWR VPWR _6300_/Y sky130_fd_sc_hd__inv_2
XFILLER_7_671 VGND VGND VPWR VPWR sky130_fd_sc_hd__fill_1
Xhold605 _6913_/Q VGND VGND VPWR VPWR _6913_/D sky130_fd_sc_hd__dlygate4sd3_1
X_7280_ _7345_/CLK _7280_/D _6560_/Y VGND VGND VPWR VPWR _7280_/Q sky130_fd_sc_hd__dfrtp_2
XFILLER_7_682 VGND VGND VPWR VPWR sky130_fd_sc_hd__decap_3
Xhold616 _6772_/Q VGND VGND VPWR VPWR _6772_/D sky130_fd_sc_hd__dlygate4sd3_1
XFILLER_116_536 VGND VGND VPWR VPWR sky130_fd_sc_hd__decap_3
Xhold627 _6837_/Q VGND VGND VPWR VPWR _6837_/D sky130_fd_sc_hd__dlygate4sd3_1
XFILLER_6_170 VGND VGND VPWR VPWR sky130_fd_sc_hd__decap_3
Xhold638 _6721_/Q VGND VGND VPWR VPWR _6721_/D sky130_fd_sc_hd__dlygate4sd3_1
Xhold649 _6930_/Q VGND VGND VPWR VPWR _6930_/D sky130_fd_sc_hd__dlygate4sd3_1
XFILLER_116_569 VGND VGND VPWR VPWR sky130_fd_sc_hd__decap_3
XTAP_TAPCELL_ROW_94_1491 VGND VPWR sky130_fd_sc_hd__tapvpwrvgnd_1
XFILLER_112_731 VGND VGND VPWR VPWR sky130_fd_sc_hd__decap_3
XFILLER_97_431 VGND VGND VPWR VPWR sky130_fd_sc_hd__decap_3
X_5113_ _5113_/A _5113_/B VGND VGND VPWR VPWR _5113_/Y sky130_fd_sc_hd__xnor2_2
XFILLER_69_155 VGND VGND VPWR VPWR sky130_fd_sc_hd__decap_3
XFILLER_111_241 VGND VGND VPWR VPWR sky130_fd_sc_hd__decap_3
XFILLER_85_615 VGND VGND VPWR VPWR sky130_fd_sc_hd__fill_1
XFILLER_57_306 VGND VGND VPWR VPWR sky130_fd_sc_hd__decap_3
XFILLER_97_486 VGND VGND VPWR VPWR sky130_fd_sc_hd__decap_3
XFILLER_85_626 VGND VGND VPWR VPWR sky130_fd_sc_hd__decap_3
XFILLER_57_317 VGND VGND VPWR VPWR sky130_fd_sc_hd__decap_3
XFILLER_57_328 VGND VGND VPWR VPWR sky130_fd_sc_hd__fill_1
XFILLER_111_274 VGND VGND VPWR VPWR sky130_fd_sc_hd__decap_3
X_5044_ _5044_/A _5044_/B VGND VGND VPWR VPWR _6988_/D sky130_fd_sc_hd__nor2_2
XPHY_EDGE_ROW_108_Left_232 VGND VGND VPWR VPWR sky130_fd_sc_hd__decap_3
XFILLER_85_659 VGND VGND VPWR VPWR sky130_fd_sc_hd__decap_3
XFILLER_84_125 VGND VGND VPWR VPWR sky130_fd_sc_hd__decap_3
XFILLER_111_296 VGND VGND VPWR VPWR sky130_fd_sc_hd__decap_3
XFILLER_38_531 VGND VGND VPWR VPWR sky130_fd_sc_hd__fill_1
XFILLER_84_147 VGND VGND VPWR VPWR sky130_fd_sc_hd__decap_3
XFILLER_72_309 VGND VGND VPWR VPWR sky130_fd_sc_hd__fill_2
XFILLER_26_704 VGND VGND VPWR VPWR sky130_fd_sc_hd__decap_3
XFILLER_65_383 VGND VGND VPWR VPWR sky130_fd_sc_hd__decap_3
XFILLER_92_180 VGND VGND VPWR VPWR sky130_fd_sc_hd__decap_3
XTAP_TAPCELL_ROW_36_732 VGND VPWR sky130_fd_sc_hd__tapvpwrvgnd_1
XFILLER_25_236 VGND VGND VPWR VPWR sky130_fd_sc_hd__decap_3
X_6995_ _7395_/CLK _6995_/D _6275_/Y VGND VGND VPWR VPWR _6995_/Q sky130_fd_sc_hd__dfrtp_2
XFILLER_80_342 VGND VGND VPWR VPWR sky130_fd_sc_hd__fill_1
XFILLER_25_258 VGND VGND VPWR VPWR sky130_fd_sc_hd__decap_3
XFILLER_41_718 VGND VGND VPWR VPWR sky130_fd_sc_hd__decap_3
XFILLER_41_729 VGND VGND VPWR VPWR sky130_fd_sc_hd__decap_3
XFILLER_33_291 VGND VGND VPWR VPWR sky130_fd_sc_hd__fill_2
X_4828_ _4970_/A1 _4810_/B _4827_/A _5033_/B2 VGND VGND VPWR VPWR _4828_/X sky130_fd_sc_hd__a22o_2
XFILLER_21_464 VGND VGND VPWR VPWR sky130_fd_sc_hd__fill_2
XPHY_EDGE_ROW_117_Left_241 VGND VGND VPWR VPWR sky130_fd_sc_hd__decap_3
XFILLER_21_475 VGND VGND VPWR VPWR sky130_fd_sc_hd__decap_3
X_4759_ _4759_/A _4777_/B VGND VGND VPWR VPWR _4760_/B sky130_fd_sc_hd__xnor2_2
XFILLER_119_352 VGND VGND VPWR VPWR sky130_fd_sc_hd__decap_3
XFILLER_107_503 VGND VGND VPWR VPWR sky130_fd_sc_hd__fill_1
XFILLER_107_514 VGND VGND VPWR VPWR sky130_fd_sc_hd__decap_3
XFILLER_4_118 VGND VGND VPWR VPWR sky130_fd_sc_hd__decap_3
XFILLER_119_396 VGND VGND VPWR VPWR sky130_fd_sc_hd__decap_3
XFILLER_107_547 VGND VGND VPWR VPWR sky130_fd_sc_hd__decap_3
XFILLER_108_32 VGND VGND VPWR VPWR sky130_fd_sc_hd__decap_3
X_6429_ _6619_/A VGND VGND VPWR VPWR _6429_/Y sky130_fd_sc_hd__inv_2
XFILLER_68_14 VGND VGND VPWR VPWR sky130_fd_sc_hd__decap_3
XFILLER_0_302 VGND VGND VPWR VPWR sky130_fd_sc_hd__decap_3
XFILLER_122_528 VGND VGND VPWR VPWR sky130_fd_sc_hd__decap_3
XFILLER_122_539 VGND VGND VPWR VPWR sky130_fd_sc_hd__decap_3
XFILLER_68_47 VGND VGND VPWR VPWR sky130_fd_sc_hd__decap_3
XFILLER_115_591 VGND VGND VPWR VPWR sky130_fd_sc_hd__decap_3
XFILLER_108_98 VGND VGND VPWR VPWR sky130_fd_sc_hd__decap_3
XFILLER_0_335 VGND VGND VPWR VPWR sky130_fd_sc_hd__fill_1
XFILLER_76_604 VGND VGND VPWR VPWR sky130_fd_sc_hd__decap_3
XFILLER_0_368 VGND VGND VPWR VPWR sky130_fd_sc_hd__fill_1
XFILLER_88_475 VGND VGND VPWR VPWR sky130_fd_sc_hd__fill_1
XFILLER_76_637 VGND VGND VPWR VPWR sky130_fd_sc_hd__decap_3
XFILLER_76_648 VGND VGND VPWR VPWR sky130_fd_sc_hd__decap_3
XFILLER_48_339 VGND VGND VPWR VPWR sky130_fd_sc_hd__decap_3
XFILLER_75_125 VGND VGND VPWR VPWR sky130_fd_sc_hd__decap_3
XFILLER_29_531 VGND VGND VPWR VPWR sky130_fd_sc_hd__decap_3
XFILLER_75_147 VGND VGND VPWR VPWR sky130_fd_sc_hd__decap_3
XFILLER_75_169 VGND VGND VPWR VPWR sky130_fd_sc_hd__decap_3
XFILLER_91_629 VGND VGND VPWR VPWR sky130_fd_sc_hd__decap_3
XFILLER_17_715 VGND VGND VPWR VPWR sky130_fd_sc_hd__decap_3
XFILLER_90_117 VGND VGND VPWR VPWR sky130_fd_sc_hd__decap_3
XFILLER_84_68 VGND VGND VPWR VPWR sky130_fd_sc_hd__decap_3
XFILLER_29_586 VGND VGND VPWR VPWR sky130_fd_sc_hd__decap_3
Xplace309 _3635_/B VGND VGND VPWR VPWR _5033_/B2 sky130_fd_sc_hd__buf_2
XFILLER_84_681 VGND VGND VPWR VPWR sky130_fd_sc_hd__decap_3
XFILLER_90_128 VGND VGND VPWR VPWR sky130_fd_sc_hd__decap_3
XFILLER_56_383 VGND VGND VPWR VPWR sky130_fd_sc_hd__decap_3
XFILLER_71_320 VGND VGND VPWR VPWR sky130_fd_sc_hd__decap_3
XTAP_TAPCELL_ROW_106_1649 VGND VPWR sky130_fd_sc_hd__tapvpwrvgnd_1
XFILLER_16_236 VGND VGND VPWR VPWR sky130_fd_sc_hd__fill_2
XFILLER_44_556 VGND VGND VPWR VPWR sky130_fd_sc_hd__decap_3
XFILLER_32_707 VGND VGND VPWR VPWR sky130_fd_sc_hd__decap_3
XFILLER_71_353 VGND VGND VPWR VPWR sky130_fd_sc_hd__decap_3
XFILLER_71_375 VGND VGND VPWR VPWR sky130_fd_sc_hd__decap_3
XFILLER_31_217 VGND VGND VPWR VPWR sky130_fd_sc_hd__decap_3
XFILLER_24_280 VGND VGND VPWR VPWR sky130_fd_sc_hd__decap_3
XTAP_TAPCELL_ROW_14_448 VGND VPWR sky130_fd_sc_hd__tapvpwrvgnd_1
XFILLER_12_464 VGND VGND VPWR VPWR sky130_fd_sc_hd__fill_1
XFILLER_8_424 VGND VGND VPWR VPWR sky130_fd_sc_hd__decap_3
XFILLER_69_9 VGND VGND VPWR VPWR sky130_fd_sc_hd__decap_3
XFILLER_99_718 VGND VGND VPWR VPWR sky130_fd_sc_hd__decap_3
XTAP_TAPCELL_ROW_117_1789 VGND VPWR sky130_fd_sc_hd__tapvpwrvgnd_1
XFILLER_99_729 VGND VGND VPWR VPWR sky130_fd_sc_hd__decap_3
XFILLER_4_663 VGND VGND VPWR VPWR sky130_fd_sc_hd__decap_3
XFILLER_3_140 VGND VGND VPWR VPWR sky130_fd_sc_hd__decap_3
XFILLER_113_517 VGND VGND VPWR VPWR sky130_fd_sc_hd__decap_3
XFILLER_3_151 VGND VGND VPWR VPWR sky130_fd_sc_hd__decap_3
XFILLER_79_420 VGND VGND VPWR VPWR sky130_fd_sc_hd__decap_3
XFILLER_4_696 VGND VGND VPWR VPWR sky130_fd_sc_hd__decap_3
XFILLER_3_184 VGND VGND VPWR VPWR sky130_fd_sc_hd__decap_3
XFILLER_79_442 VGND VGND VPWR VPWR sky130_fd_sc_hd__decap_3
XFILLER_121_550 VGND VGND VPWR VPWR sky130_fd_sc_hd__decap_3
XFILLER_67_615 VGND VGND VPWR VPWR sky130_fd_sc_hd__fill_1
XFILLER_121_561 VGND VGND VPWR VPWR sky130_fd_sc_hd__decap_3
XFILLER_67_626 VGND VGND VPWR VPWR sky130_fd_sc_hd__decap_3
XFILLER_66_103 VGND VGND VPWR VPWR sky130_fd_sc_hd__decap_3
XFILLER_58_80 VGND VGND VPWR VPWR sky130_fd_sc_hd__decap_3
XFILLER_121_594 VGND VGND VPWR VPWR sky130_fd_sc_hd__decap_3
XFILLER_94_445 VGND VGND VPWR VPWR sky130_fd_sc_hd__decap_3
XFILLER_67_659 VGND VGND VPWR VPWR sky130_fd_sc_hd__decap_3
XFILLER_82_607 VGND VGND VPWR VPWR sky130_fd_sc_hd__decap_3
XFILLER_54_309 VGND VGND VPWR VPWR sky130_fd_sc_hd__decap_3
XFILLER_94_489 VGND VGND VPWR VPWR sky130_fd_sc_hd__fill_1
XFILLER_35_501 VGND VGND VPWR VPWR sky130_fd_sc_hd__decap_3
XFILLER_47_383 VGND VGND VPWR VPWR sky130_fd_sc_hd__decap_3
XFILLER_81_139 VGND VGND VPWR VPWR sky130_fd_sc_hd__fill_2
XFILLER_74_180 VGND VGND VPWR VPWR sky130_fd_sc_hd__decap_3
XFILLER_90_640 VGND VGND VPWR VPWR sky130_fd_sc_hd__decap_3
XFILLER_74_191 VGND VGND VPWR VPWR sky130_fd_sc_hd__decap_3
XFILLER_90_651 VGND VGND VPWR VPWR sky130_fd_sc_hd__decap_3
XFILLER_23_718 VGND VGND VPWR VPWR sky130_fd_sc_hd__decap_3
XTAP_TAPCELL_ROW_33_702 VGND VPWR sky130_fd_sc_hd__tapvpwrvgnd_1
X_6780_ _6926_/CLK _6780_/D VGND VGND VPWR VPWR _6780_/Q sky130_fd_sc_hd__dfxtp_2
XFILLER_23_729 VGND VGND VPWR VPWR sky130_fd_sc_hd__decap_3
X_3992_ _5156_/S _5647_/A VGND VGND VPWR VPWR _3992_/Y sky130_fd_sc_hd__nand2_2
XFILLER_90_684 VGND VGND VPWR VPWR sky130_fd_sc_hd__decap_3
XFILLER_62_397 VGND VGND VPWR VPWR sky130_fd_sc_hd__decap_3
X_5731_ _7371_/Q hold915/X _5735_/S VGND VGND VPWR VPWR _6715_/D sky130_fd_sc_hd__mux2_2
XFILLER_50_548 VGND VGND VPWR VPWR sky130_fd_sc_hd__fill_1
X_5662_ _5662_/A _5662_/B _5662_/C _5661_/X VGND VGND VPWR VPWR _5663_/D sky130_fd_sc_hd__or4b_4
X_4613_ _4614_/B _4613_/B _5113_/A VGND VGND VPWR VPWR _4617_/B sky130_fd_sc_hd__and3_2
X_7401_ _7401_/CLK _7401_/D _6681_/Y VGND VGND VPWR VPWR _7401_/Q sky130_fd_sc_hd__dfrtp_2
XFILLER_30_294 VGND VGND VPWR VPWR sky130_fd_sc_hd__decap_3
X_5593_ _5593_/A _5595_/B VGND VGND VPWR VPWR _7031_/D sky130_fd_sc_hd__or2_2
XTAP_TAPCELL_ROW_96_1520 VGND VPWR sky130_fd_sc_hd__tapvpwrvgnd_1
X_7332_ _7359_/CLK _7332_/D _6612_/Y VGND VGND VPWR VPWR _7332_/Q sky130_fd_sc_hd__dfrtp_2
XFILLER_116_300 VGND VGND VPWR VPWR sky130_fd_sc_hd__fill_1
X_4544_ _4544_/A _4559_/B VGND VGND VPWR VPWR _7308_/D sky130_fd_sc_hd__and2_2
X_7263_ _7362_/CLK _7263_/D _6543_/Y VGND VGND VPWR VPWR _7263_/Q sky130_fd_sc_hd__dfrtp_2
XFILLER_89_228 VGND VGND VPWR VPWR sky130_fd_sc_hd__decap_3
XFILLER_104_539 VGND VGND VPWR VPWR sky130_fd_sc_hd__decap_3
X_3426_ _3589_/A _3591_/A _3589_/B _3590_/C VGND VGND VPWR VPWR _3427_/B sky130_fd_sc_hd__or4_4
X_7194_ _7325_/CLK _7194_/D _6474_/Y VGND VGND VPWR VPWR _7194_/Q sky130_fd_sc_hd__dfrtp_2
X_3357_ _4537_/B VGND VGND VPWR VPWR _3449_/A sky130_fd_sc_hd__inv_6
XFILLER_100_701 VGND VGND VPWR VPWR sky130_fd_sc_hd__decap_3
XFILLER_58_626 VGND VGND VPWR VPWR sky130_fd_sc_hd__decap_3
XFILLER_57_103 VGND VGND VPWR VPWR sky130_fd_sc_hd__decap_3
XFILLER_112_572 VGND VGND VPWR VPWR sky130_fd_sc_hd__decap_3
Xhold1102 _7202_/Q VGND VGND VPWR VPWR _5256_/A0 sky130_fd_sc_hd__dlygate4sd3_1
Xhold1113 _7288_/Q VGND VGND VPWR VPWR _4585_/A sky130_fd_sc_hd__dlygate4sd3_1
XFILLER_58_648 VGND VGND VPWR VPWR sky130_fd_sc_hd__decap_3
XFILLER_100_734 VGND VGND VPWR VPWR sky130_fd_sc_hd__fill_1
Xhold1124 _7240_/Q VGND VGND VPWR VPWR _5175_/A sky130_fd_sc_hd__dlygate4sd3_1
Xhold1135 _7170_/Q VGND VGND VPWR VPWR _5321_/A0 sky130_fd_sc_hd__dlygate4sd3_1
Xhold1146 _7171_/Q VGND VGND VPWR VPWR _5319_/A0 sky130_fd_sc_hd__dlygate4sd3_1
XFILLER_57_158 VGND VGND VPWR VPWR sky130_fd_sc_hd__decap_3
X_5027_ _5092_/C _5024_/X _6990_/D _5666_/A VGND VGND VPWR VPWR _5027_/X sky130_fd_sc_hd__a22o_2
Xhold1157 _7161_/Q VGND VGND VPWR VPWR _5340_/A0 sky130_fd_sc_hd__dlygate4sd3_1
XFILLER_57_169 VGND VGND VPWR VPWR sky130_fd_sc_hd__fill_1
Xhold1168 _7248_/Q VGND VGND VPWR VPWR _5157_/A0 sky130_fd_sc_hd__dlygate4sd3_1
XFILLER_73_629 VGND VGND VPWR VPWR sky130_fd_sc_hd__decap_3
Xhold1179 _7403_/Q VGND VGND VPWR VPWR _3693_/A0 sky130_fd_sc_hd__dlygate4sd3_1
XFILLER_85_489 VGND VGND VPWR VPWR sky130_fd_sc_hd__fill_1
XFILLER_72_106 VGND VGND VPWR VPWR sky130_fd_sc_hd__decap_3
XFILLER_66_681 VGND VGND VPWR VPWR sky130_fd_sc_hd__decap_3
XFILLER_53_320 VGND VGND VPWR VPWR sky130_fd_sc_hd__decap_3
XFILLER_14_707 VGND VGND VPWR VPWR sky130_fd_sc_hd__decap_3
XFILLER_81_662 VGND VGND VPWR VPWR sky130_fd_sc_hd__decap_3
XFILLER_81_673 VGND VGND VPWR VPWR sky130_fd_sc_hd__decap_3
XFILLER_53_364 VGND VGND VPWR VPWR sky130_fd_sc_hd__decap_3
XFILLER_26_589 VGND VGND VPWR VPWR sky130_fd_sc_hd__decap_3
X_6978_ _6978_/CLK _6978_/D VGND VGND VPWR VPWR _6978_/Q sky130_fd_sc_hd__dfxtp_2
XFILLER_13_228 VGND VGND VPWR VPWR sky130_fd_sc_hd__decap_3
XFILLER_80_183 VGND VGND VPWR VPWR sky130_fd_sc_hd__decap_3
XFILLER_110_44 VGND VGND VPWR VPWR sky130_fd_sc_hd__decap_3
XFILLER_41_559 VGND VGND VPWR VPWR sky130_fd_sc_hd__fill_1
XFILLER_70_15 VGND VGND VPWR VPWR sky130_fd_sc_hd__decap_3
XTAP_TAPCELL_ROW_101_1579 VGND VPWR sky130_fd_sc_hd__tapvpwrvgnd_1
XTAP_TAPCELL_ROW_11_407 VGND VPWR sky130_fd_sc_hd__tapvpwrvgnd_1
XFILLER_21_261 VGND VGND VPWR VPWR sky130_fd_sc_hd__decap_3
XFILLER_5_416 VGND VGND VPWR VPWR sky130_fd_sc_hd__fill_2
XFILLER_119_42 VGND VGND VPWR VPWR sky130_fd_sc_hd__decap_3
XFILLER_119_182 VGND VGND VPWR VPWR sky130_fd_sc_hd__decap_3
XFILLER_119_75 VGND VGND VPWR VPWR sky130_fd_sc_hd__decap_3
XFILLER_107_333 VGND VGND VPWR VPWR sky130_fd_sc_hd__decap_3
XFILLER_79_57 VGND VGND VPWR VPWR sky130_fd_sc_hd__decap_3
XFILLER_1_600 VGND VGND VPWR VPWR sky130_fd_sc_hd__decap_3
XFILLER_107_388 VGND VGND VPWR VPWR sky130_fd_sc_hd__decap_3
Xhold980 _7016_/Q VGND VGND VPWR VPWR _5624_/A sky130_fd_sc_hd__dlygate4sd3_1
Xhold991 _7200_/Q VGND VGND VPWR VPWR hold991/X sky130_fd_sc_hd__dlygate4sd3_1
XFILLER_1_644 VGND VGND VPWR VPWR sky130_fd_sc_hd__decap_3
XFILLER_122_358 VGND VGND VPWR VPWR sky130_fd_sc_hd__decap_3
XFILLER_88_250 VGND VGND VPWR VPWR sky130_fd_sc_hd__fill_2
XFILLER_103_550 VGND VGND VPWR VPWR sky130_fd_sc_hd__decap_3
XFILLER_88_261 VGND VGND VPWR VPWR sky130_fd_sc_hd__decap_3
XFILLER_49_615 VGND VGND VPWR VPWR sky130_fd_sc_hd__fill_1
XFILLER_103_561 VGND VGND VPWR VPWR sky130_fd_sc_hd__decap_3
XFILLER_49_626 VGND VGND VPWR VPWR sky130_fd_sc_hd__decap_3
XFILLER_1_688 VGND VGND VPWR VPWR sky130_fd_sc_hd__decap_3
XFILLER_88_283 VGND VGND VPWR VPWR sky130_fd_sc_hd__decap_3
XFILLER_103_594 VGND VGND VPWR VPWR sky130_fd_sc_hd__decap_3
XFILLER_49_659 VGND VGND VPWR VPWR sky130_fd_sc_hd__decap_3
XFILLER_64_607 VGND VGND VPWR VPWR sky130_fd_sc_hd__decap_3
XFILLER_36_309 VGND VGND VPWR VPWR sky130_fd_sc_hd__decap_3
XFILLER_91_404 VGND VGND VPWR VPWR sky130_fd_sc_hd__decap_3
XFILLER_48_169 VGND VGND VPWR VPWR sky130_fd_sc_hd__decap_3
XTAP_TAPCELL_ROW_19_518 VGND VPWR sky130_fd_sc_hd__tapvpwrvgnd_1
XFILLER_91_426 VGND VGND VPWR VPWR sky130_fd_sc_hd__decap_3
XTAP_TAPCELL_ROW_67_1132 VGND VPWR sky130_fd_sc_hd__tapvpwrvgnd_1
XTAP_TAPCELL_ROW_67_1143 VGND VPWR sky130_fd_sc_hd__tapvpwrvgnd_1
XFILLER_72_640 VGND VGND VPWR VPWR sky130_fd_sc_hd__decap_3
XFILLER_72_651 VGND VGND VPWR VPWR sky130_fd_sc_hd__decap_3
XFILLER_17_567 VGND VGND VPWR VPWR sky130_fd_sc_hd__decap_3
XFILLER_32_504 VGND VGND VPWR VPWR sky130_fd_sc_hd__decap_3
XFILLER_72_684 VGND VGND VPWR VPWR sky130_fd_sc_hd__decap_3
XFILLER_71_172 VGND VGND VPWR VPWR sky130_fd_sc_hd__fill_2
XTAP_TAPCELL_ROW_80_1310 VGND VPWR sky130_fd_sc_hd__tapvpwrvgnd_1
XFILLER_9_700 VGND VGND VPWR VPWR sky130_fd_sc_hd__decap_3
XFILLER_8_210 VGND VGND VPWR VPWR sky130_fd_sc_hd__decap_3
XTAP_TAPCELL_ROW_119_1818 VGND VPWR sky130_fd_sc_hd__tapvpwrvgnd_1
XFILLER_40_592 VGND VGND VPWR VPWR sky130_fd_sc_hd__decap_3
XFILLER_117_108 VGND VGND VPWR VPWR sky130_fd_sc_hd__decap_3
XFILLER_8_265 VGND VGND VPWR VPWR sky130_fd_sc_hd__fill_2
XFILLER_117_119 VGND VGND VPWR VPWR sky130_fd_sc_hd__decap_3
XFILLER_67_6 VGND VGND VPWR VPWR sky130_fd_sc_hd__decap_3
Xoutput507 place205/X VGND VGND VPWR VPWR instruction_out[25] sky130_fd_sc_hd__clkdlybuf4s25_1
Xoutput518 _5362_/C VGND VGND VPWR VPWR instruction_out[8] sky130_fd_sc_hd__clkdlybuf4s25_1
XTAP_TAPCELL_ROW_78_1283 VGND VPWR sky130_fd_sc_hd__tapvpwrvgnd_1
Xoutput529 _6995_/Q VGND VGND VPWR VPWR pc_out[18] sky130_fd_sc_hd__clkdlybuf4s25_1
X_4260_ _7262_/Q _4356_/A2 _3966_/S _7326_/Q VGND VGND VPWR VPWR _4264_/A sky130_fd_sc_hd__a22o_2
XFILLER_99_559 VGND VGND VPWR VPWR sky130_fd_sc_hd__fill_1
XFILLER_4_493 VGND VGND VPWR VPWR sky130_fd_sc_hd__fill_2
XTAP_TAPCELL_ROW_91_1450 VGND VPWR sky130_fd_sc_hd__tapvpwrvgnd_1
XFILLER_86_209 VGND VGND VPWR VPWR sky130_fd_sc_hd__decap_3
XFILLER_79_250 VGND VGND VPWR VPWR sky130_fd_sc_hd__decap_3
X_4191_ _7071_/Q _4265_/B _4205_/A VGND VGND VPWR VPWR _4637_/C sky130_fd_sc_hd__o21a_2
XFILLER_95_721 VGND VGND VPWR VPWR sky130_fd_sc_hd__decap_3
XFILLER_95_732 VGND VGND VPWR VPWR sky130_fd_sc_hd__decap_3
XFILLER_67_423 VGND VGND VPWR VPWR sky130_fd_sc_hd__decap_3
XFILLER_94_253 VGND VGND VPWR VPWR sky130_fd_sc_hd__decap_3
XFILLER_39_169 VGND VGND VPWR VPWR sky130_fd_sc_hd__fill_2
XFILLER_55_629 VGND VGND VPWR VPWR sky130_fd_sc_hd__decap_3
XFILLER_48_681 VGND VGND VPWR VPWR sky130_fd_sc_hd__decap_3
XFILLER_94_297 VGND VGND VPWR VPWR sky130_fd_sc_hd__decap_3
X_6901_ clkload4/A _6901_/D VGND VGND VPWR VPWR _6901_/Q sky130_fd_sc_hd__dfxtp_2
XFILLER_35_320 VGND VGND VPWR VPWR sky130_fd_sc_hd__decap_3
XFILLER_63_662 VGND VGND VPWR VPWR sky130_fd_sc_hd__decap_3
XTAP_TAPCELL_ROW_46_860 VGND VPWR sky130_fd_sc_hd__tapvpwrvgnd_1
XFILLER_63_673 VGND VGND VPWR VPWR sky130_fd_sc_hd__decap_3
XTAP_TAPCELL_ROW_46_871 VGND VPWR sky130_fd_sc_hd__tapvpwrvgnd_1
X_6832_ _6967_/CLK _6832_/D VGND VGND VPWR VPWR _6832_/Q sky130_fd_sc_hd__dfxtp_2
XFILLER_90_470 VGND VGND VPWR VPWR sky130_fd_sc_hd__decap_3
XFILLER_50_301 VGND VGND VPWR VPWR sky130_fd_sc_hd__decap_3
XFILLER_35_375 VGND VGND VPWR VPWR sky130_fd_sc_hd__decap_3
XFILLER_62_172 VGND VGND VPWR VPWR sky130_fd_sc_hd__fill_2
XFILLER_50_312 VGND VGND VPWR VPWR sky130_fd_sc_hd__decap_3
XFILLER_24_19 VGND VGND VPWR VPWR sky130_fd_sc_hd__fill_1
XFILLER_23_559 VGND VGND VPWR VPWR sky130_fd_sc_hd__fill_1
X_3975_ _7353_/Q _4517_/A0 _3975_/S VGND VGND VPWR VPWR _7353_/D sky130_fd_sc_hd__mux2_2
X_6763_ clkload9/A _6763_/D VGND VGND VPWR VPWR _6763_/Q sky130_fd_sc_hd__dfxtp_2
XFILLER_50_345 VGND VGND VPWR VPWR sky130_fd_sc_hd__decap_3
XFILLER_50_378 VGND VGND VPWR VPWR sky130_fd_sc_hd__decap_3
X_6694_ _7345_/CLK _6694_/D VGND VGND VPWR VPWR _6694_/Q sky130_fd_sc_hd__dfxtp_2
XFILLER_109_609 VGND VGND VPWR VPWR sky130_fd_sc_hd__decap_3
X_5645_ _3386_/A _5129_/B _3519_/B _5644_/X VGND VGND VPWR VPWR _5645_/X sky130_fd_sc_hd__o31a_2
XFILLER_108_119 VGND VGND VPWR VPWR sky130_fd_sc_hd__decap_3
XFILLER_117_620 VGND VGND VPWR VPWR sky130_fd_sc_hd__decap_3
X_5576_ _7041_/Q _5647_/A _5015_/X VGND VGND VPWR VPWR _7041_/D sky130_fd_sc_hd__a21o_2
XFILLER_117_653 VGND VGND VPWR VPWR sky130_fd_sc_hd__decap_3
X_7315_ _7318_/CLK _7315_/D _6595_/Y VGND VGND VPWR VPWR _7315_/Q sky130_fd_sc_hd__dfrtp_2
XFILLER_116_141 VGND VGND VPWR VPWR sky130_fd_sc_hd__decap_3
XFILLER_117_697 VGND VGND VPWR VPWR sky130_fd_sc_hd__decap_3
X_4458_ _4458_/A _4039_/A VGND VGND VPWR VPWR _4458_/X sky130_fd_sc_hd__or2b_2
X_7246_ _7370_/CLK _7246_/D _6526_/Y VGND VGND VPWR VPWR _7246_/Q sky130_fd_sc_hd__dfrtp_2
XFILLER_104_347 VGND VGND VPWR VPWR sky130_fd_sc_hd__decap_3
X_3409_ _3449_/A _3449_/B _3421_/C _3409_/D VGND VGND VPWR VPWR _3409_/X sky130_fd_sc_hd__and4_2
X_7177_ _7405_/CLK _7177_/D _6457_/Y VGND VGND VPWR VPWR _7177_/Q sky130_fd_sc_hd__dfrtp_2
X_4389_ _7081_/Q _4102_/B _4432_/B1 _4388_/X VGND VGND VPWR VPWR _4396_/A sky130_fd_sc_hd__o211ai_2
XFILLER_86_710 VGND VGND VPWR VPWR sky130_fd_sc_hd__decap_3
XFILLER_58_401 VGND VGND VPWR VPWR sky130_fd_sc_hd__decap_3
XFILLER_98_592 VGND VGND VPWR VPWR sky130_fd_sc_hd__decap_3
XFILLER_105_33 VGND VGND VPWR VPWR sky130_fd_sc_hd__decap_3
XFILLER_58_456 VGND VGND VPWR VPWR sky130_fd_sc_hd__decap_3
XFILLER_85_253 VGND VGND VPWR VPWR sky130_fd_sc_hd__decap_3
XFILLER_18_309 VGND VGND VPWR VPWR sky130_fd_sc_hd__decap_3
XFILLER_105_77 VGND VGND VPWR VPWR sky130_fd_sc_hd__decap_3
XFILLER_46_629 VGND VGND VPWR VPWR sky130_fd_sc_hd__decap_3
XFILLER_100_586 VGND VGND VPWR VPWR sky130_fd_sc_hd__fill_2
XFILLER_54_640 VGND VGND VPWR VPWR sky130_fd_sc_hd__decap_3
XFILLER_54_651 VGND VGND VPWR VPWR sky130_fd_sc_hd__decap_3
XFILLER_26_342 VGND VGND VPWR VPWR sky130_fd_sc_hd__decap_3
XFILLER_121_21 VGND VGND VPWR VPWR sky130_fd_sc_hd__decap_3
XTAP_TAPCELL_ROW_103_1608 VGND VPWR sky130_fd_sc_hd__tapvpwrvgnd_1
XFILLER_53_150 VGND VGND VPWR VPWR sky130_fd_sc_hd__decap_3
XFILLER_54_684 VGND VGND VPWR VPWR sky130_fd_sc_hd__decap_3
XFILLER_121_54 VGND VGND VPWR VPWR sky130_fd_sc_hd__fill_2
XFILLER_41_312 VGND VGND VPWR VPWR sky130_fd_sc_hd__decap_3
XFILLER_26_386 VGND VGND VPWR VPWR sky130_fd_sc_hd__decap_3
XFILLER_14_537 VGND VGND VPWR VPWR sky130_fd_sc_hd__decap_3
XFILLER_81_492 VGND VGND VPWR VPWR sky130_fd_sc_hd__decap_3
XFILLER_121_87 VGND VGND VPWR VPWR sky130_fd_sc_hd__decap_3
XTAP_TAPCELL_ROW_24_576 VGND VPWR sky130_fd_sc_hd__tapvpwrvgnd_1
XFILLER_14_52 VGND VGND VPWR VPWR sky130_fd_sc_hd__decap_3
XFILLER_10_710 VGND VGND VPWR VPWR sky130_fd_sc_hd__decap_3
XTAP_TAPCELL_ROW_62_1073 VGND VPWR sky130_fd_sc_hd__tapvpwrvgnd_1
XFILLER_22_581 VGND VGND VPWR VPWR sky130_fd_sc_hd__decap_3
XFILLER_22_592 VGND VGND VPWR VPWR sky130_fd_sc_hd__decap_3
XFILLER_14_85 VGND VGND VPWR VPWR sky130_fd_sc_hd__fill_1
XFILLER_6_725 VGND VGND VPWR VPWR sky130_fd_sc_hd__decap_3
XFILLER_108_631 VGND VGND VPWR VPWR sky130_fd_sc_hd__decap_3
XFILLER_5_257 VGND VGND VPWR VPWR sky130_fd_sc_hd__decap_3
XFILLER_108_675 VGND VGND VPWR VPWR sky130_fd_sc_hd__decap_3
XFILLER_107_152 VGND VGND VPWR VPWR sky130_fd_sc_hd__decap_3
XFILLER_5_279 VGND VGND VPWR VPWR sky130_fd_sc_hd__fill_1
XTAP_TAPCELL_ROW_114_1748 VGND VPWR sky130_fd_sc_hd__tapvpwrvgnd_1
XFILLER_122_100 VGND VGND VPWR VPWR sky130_fd_sc_hd__decap_3
XFILLER_107_196 VGND VGND VPWR VPWR sky130_fd_sc_hd__decap_3
XFILLER_123_656 VGND VGND VPWR VPWR sky130_fd_sc_hd__decap_3
XFILLER_68_209 VGND VGND VPWR VPWR sky130_fd_sc_hd__decap_3
XFILLER_89_570 VGND VGND VPWR VPWR sky130_fd_sc_hd__decap_3
XFILLER_110_317 VGND VGND VPWR VPWR sky130_fd_sc_hd__decap_3
XFILLER_77_721 VGND VGND VPWR VPWR sky130_fd_sc_hd__decap_3
XFILLER_77_732 VGND VGND VPWR VPWR sky130_fd_sc_hd__decap_3
XFILLER_39_60 VGND VGND VPWR VPWR sky130_fd_sc_hd__decap_3
XFILLER_1_496 VGND VGND VPWR VPWR sky130_fd_sc_hd__decap_3
XFILLER_103_380 VGND VGND VPWR VPWR sky130_fd_sc_hd__fill_1
XFILLER_76_231 VGND VGND VPWR VPWR sky130_fd_sc_hd__decap_3
XFILLER_76_253 VGND VGND VPWR VPWR sky130_fd_sc_hd__decap_3
XFILLER_92_713 VGND VGND VPWR VPWR sky130_fd_sc_hd__decap_3
XFILLER_37_629 VGND VGND VPWR VPWR sky130_fd_sc_hd__decap_3
XFILLER_91_234 VGND VGND VPWR VPWR sky130_fd_sc_hd__decap_3
XFILLER_64_459 VGND VGND VPWR VPWR sky130_fd_sc_hd__decap_3
XFILLER_45_662 VGND VGND VPWR VPWR sky130_fd_sc_hd__decap_3
XFILLER_91_278 VGND VGND VPWR VPWR sky130_fd_sc_hd__fill_2
XFILLER_45_673 VGND VGND VPWR VPWR sky130_fd_sc_hd__decap_3
XFILLER_17_364 VGND VGND VPWR VPWR sky130_fd_sc_hd__decap_3
XFILLER_60_610 VGND VGND VPWR VPWR sky130_fd_sc_hd__decap_3
XFILLER_72_470 VGND VGND VPWR VPWR sky130_fd_sc_hd__decap_3
XFILLER_32_312 VGND VGND VPWR VPWR sky130_fd_sc_hd__decap_3
XTAP_TAPCELL_ROW_43_830 VGND VPWR sky130_fd_sc_hd__tapvpwrvgnd_1
XFILLER_60_643 VGND VGND VPWR VPWR sky130_fd_sc_hd__fill_1
XFILLER_60_654 VGND VGND VPWR VPWR sky130_fd_sc_hd__decap_3
XFILLER_32_345 VGND VGND VPWR VPWR sky130_fd_sc_hd__decap_3
XFILLER_60_687 VGND VGND VPWR VPWR sky130_fd_sc_hd__decap_3
X_3760_ _6933_/Q _3898_/A2 _3767_/A2 _6707_/Q VGND VGND VPWR VPWR _3760_/X sky130_fd_sc_hd__a22o_2
XFILLER_13_570 VGND VGND VPWR VPWR sky130_fd_sc_hd__decap_3
XFILLER_9_541 VGND VGND VPWR VPWR sky130_fd_sc_hd__decap_3
XFILLER_71_91 VGND VGND VPWR VPWR sky130_fd_sc_hd__fill_2
X_3691_ _6941_/Q _3898_/A2 _3759_/A2 _6805_/Q VGND VGND VPWR VPWR _3691_/X sky130_fd_sc_hd__a22o_2
XFILLER_9_585 VGND VGND VPWR VPWR sky130_fd_sc_hd__decap_3
XFILLER_118_439 VGND VGND VPWR VPWR sky130_fd_sc_hd__decap_3
XFILLER_65_3 VGND VGND VPWR VPWR sky130_fd_sc_hd__decap_3
XFILLER_114_601 VGND VGND VPWR VPWR sky130_fd_sc_hd__decap_3
X_4312_ _4394_/A _4337_/B _4311_/X VGND VGND VPWR VPWR _4313_/D sky130_fd_sc_hd__or3b_2
X_7100_ _7356_/CLK _7100_/D _6380_/Y VGND VGND VPWR VPWR _7100_/Q sky130_fd_sc_hd__dfrtp_2
XFILLER_114_634 VGND VGND VPWR VPWR sky130_fd_sc_hd__decap_3
XFILLER_99_334 VGND VGND VPWR VPWR sky130_fd_sc_hd__fill_2
X_5292_ _5292_/A0 _4470_/X _5292_/S VGND VGND VPWR VPWR _7183_/D sky130_fd_sc_hd__mux2_2
XFILLER_114_645 VGND VGND VPWR VPWR sky130_fd_sc_hd__decap_3
XFILLER_113_122 VGND VGND VPWR VPWR sky130_fd_sc_hd__fill_2
XFILLER_4_290 VGND VGND VPWR VPWR sky130_fd_sc_hd__decap_3
X_7031_ _7355_/CLK _7031_/D _6311_/Y VGND VGND VPWR VPWR _7031_/Q sky130_fd_sc_hd__dfrtp_2
XFILLER_114_678 VGND VGND VPWR VPWR sky130_fd_sc_hd__decap_3
X_4243_ _4620_/A _5032_/A VGND VGND VPWR VPWR _4243_/Y sky130_fd_sc_hd__nor2_2
XFILLER_68_710 VGND VGND VPWR VPWR sky130_fd_sc_hd__decap_3
XFILLER_101_317 VGND VGND VPWR VPWR sky130_fd_sc_hd__decap_3
XFILLER_67_220 VGND VGND VPWR VPWR sky130_fd_sc_hd__decap_3
X_4174_ _7296_/Q _4505_/S _4261_/A2 _7360_/Q VGND VGND VPWR VPWR _4174_/X sky130_fd_sc_hd__a22o_2
XFILLER_28_607 VGND VGND VPWR VPWR sky130_fd_sc_hd__decap_3
XFILLER_95_573 VGND VGND VPWR VPWR sky130_fd_sc_hd__decap_3
XFILLER_83_724 VGND VGND VPWR VPWR sky130_fd_sc_hd__decap_3
XFILLER_82_212 VGND VGND VPWR VPWR sky130_fd_sc_hd__decap_3
XFILLER_55_426 VGND VGND VPWR VPWR sky130_fd_sc_hd__fill_1
XFILLER_27_128 VGND VGND VPWR VPWR sky130_fd_sc_hd__decap_3
XFILLER_55_459 VGND VGND VPWR VPWR sky130_fd_sc_hd__decap_3
XFILLER_36_640 VGND VGND VPWR VPWR sky130_fd_sc_hd__decap_3
XFILLER_82_256 VGND VGND VPWR VPWR sky130_fd_sc_hd__decap_3
XFILLER_36_651 VGND VGND VPWR VPWR sky130_fd_sc_hd__decap_3
XFILLER_82_289 VGND VGND VPWR VPWR sky130_fd_sc_hd__fill_2
XFILLER_63_470 VGND VGND VPWR VPWR sky130_fd_sc_hd__decap_3
XFILLER_51_610 VGND VGND VPWR VPWR sky130_fd_sc_hd__decap_3
XFILLER_36_684 VGND VGND VPWR VPWR sky130_fd_sc_hd__decap_3
XFILLER_35_172 VGND VGND VPWR VPWR sky130_fd_sc_hd__decap_3
XFILLER_51_632 VGND VGND VPWR VPWR sky130_fd_sc_hd__decap_3
X_6815_ _6967_/CLK _6815_/D VGND VGND VPWR VPWR _6815_/Q sky130_fd_sc_hd__dfxtp_2
XFILLER_51_665 VGND VGND VPWR VPWR sky130_fd_sc_hd__decap_3
XFILLER_51_676 VGND VGND VPWR VPWR sky130_fd_sc_hd__decap_3
XFILLER_11_529 VGND VGND VPWR VPWR sky130_fd_sc_hd__fill_2
X_6746_ _6960_/CLK _6746_/D VGND VGND VPWR VPWR _6746_/Q sky130_fd_sc_hd__dfxtp_2
XFILLER_50_175 VGND VGND VPWR VPWR sky130_fd_sc_hd__decap_3
X_3958_ _7361_/Q _4501_/A0 _3958_/S VGND VGND VPWR VPWR _7361_/D sky130_fd_sc_hd__mux2_2
XFILLER_50_197 VGND VGND VPWR VPWR sky130_fd_sc_hd__decap_3
XTAP_TAPCELL_ROW_21_535 VGND VPWR sky130_fd_sc_hd__tapvpwrvgnd_1
XTAP_TAPCELL_ROW_21_546 VGND VPWR sky130_fd_sc_hd__tapvpwrvgnd_1
X_3889_ _6834_/Q _3889_/A2 _3890_/B1 _6829_/Q _3888_/X VGND VGND VPWR VPWR _3889_/X
+ sky130_fd_sc_hd__a221o_2
X_6677_ _6686_/A VGND VGND VPWR VPWR _6677_/Y sky130_fd_sc_hd__inv_2
XFILLER_109_417 VGND VGND VPWR VPWR sky130_fd_sc_hd__decap_3
X_5628_ _5628_/A _5633_/B VGND VGND VPWR VPWR _7014_/D sky130_fd_sc_hd__or2_2
XFILLER_3_706 VGND VGND VPWR VPWR sky130_fd_sc_hd__decap_3
XFILLER_105_612 VGND VGND VPWR VPWR sky130_fd_sc_hd__decap_3
XFILLER_105_623 VGND VGND VPWR VPWR sky130_fd_sc_hd__decap_3
XFILLER_104_100 VGND VGND VPWR VPWR sky130_fd_sc_hd__decap_3
XFILLER_117_494 VGND VGND VPWR VPWR sky130_fd_sc_hd__decap_3
XFILLER_2_249 VGND VGND VPWR VPWR sky130_fd_sc_hd__decap_3
XFILLER_105_656 VGND VGND VPWR VPWR sky130_fd_sc_hd__decap_3
XFILLER_78_507 VGND VGND VPWR VPWR sky130_fd_sc_hd__decap_3
XFILLER_104_144 VGND VGND VPWR VPWR sky130_fd_sc_hd__decap_3
XFILLER_120_604 VGND VGND VPWR VPWR sky130_fd_sc_hd__decap_3
XFILLER_116_32 VGND VGND VPWR VPWR sky130_fd_sc_hd__decap_3
X_7229_ _7356_/CLK _7229_/D _6509_/Y VGND VGND VPWR VPWR _7229_/Q sky130_fd_sc_hd__dfrtp_2
XFILLER_76_14 VGND VGND VPWR VPWR sky130_fd_sc_hd__decap_3
XFILLER_59_721 VGND VGND VPWR VPWR sky130_fd_sc_hd__decap_3
XFILLER_120_637 VGND VGND VPWR VPWR sky130_fd_sc_hd__decap_3
XFILLER_116_65 VGND VGND VPWR VPWR sky130_fd_sc_hd__decap_3
XFILLER_59_732 VGND VGND VPWR VPWR sky130_fd_sc_hd__decap_3
XFILLER_120_648 VGND VGND VPWR VPWR sky130_fd_sc_hd__decap_3
XFILLER_58_253 VGND VGND VPWR VPWR sky130_fd_sc_hd__fill_1
XFILLER_74_713 VGND VGND VPWR VPWR sky130_fd_sc_hd__decap_3
XFILLER_19_629 VGND VGND VPWR VPWR sky130_fd_sc_hd__decap_3
XFILLER_18_106 VGND VGND VPWR VPWR sky130_fd_sc_hd__fill_1
XFILLER_86_595 VGND VGND VPWR VPWR sky130_fd_sc_hd__decap_3
XFILLER_73_212 VGND VGND VPWR VPWR sky130_fd_sc_hd__decap_3
XTAP_TAPCELL_ROW_29_646 VGND VPWR sky130_fd_sc_hd__tapvpwrvgnd_1
XFILLER_73_234 VGND VGND VPWR VPWR sky130_fd_sc_hd__decap_3
XFILLER_73_267 VGND VGND VPWR VPWR sky130_fd_sc_hd__decap_3
XFILLER_27_662 VGND VGND VPWR VPWR sky130_fd_sc_hd__decap_3
XFILLER_73_278 VGND VGND VPWR VPWR sky130_fd_sc_hd__fill_2
XFILLER_61_418 VGND VGND VPWR VPWR sky130_fd_sc_hd__decap_3
XFILLER_27_673 VGND VGND VPWR VPWR sky130_fd_sc_hd__decap_3
XTAP_TAPCELL_ROW_1_282 VGND VPWR sky130_fd_sc_hd__tapvpwrvgnd_1
XTAP_TAPCELL_ROW_64_1102 VGND VPWR sky130_fd_sc_hd__tapvpwrvgnd_1
XFILLER_42_610 VGND VGND VPWR VPWR sky130_fd_sc_hd__decap_3
XFILLER_14_312 VGND VGND VPWR VPWR sky130_fd_sc_hd__decap_3
XFILLER_42_643 VGND VGND VPWR VPWR sky130_fd_sc_hd__fill_1
XFILLER_42_654 VGND VGND VPWR VPWR sky130_fd_sc_hd__decap_3
XFILLER_42_687 VGND VGND VPWR VPWR sky130_fd_sc_hd__decap_3
XFILLER_41_175 VGND VGND VPWR VPWR sky130_fd_sc_hd__fill_1
XFILLER_14_389 VGND VGND VPWR VPWR sky130_fd_sc_hd__decap_3
XFILLER_10_551 VGND VGND VPWR VPWR sky130_fd_sc_hd__decap_3
XFILLER_6_533 VGND VGND VPWR VPWR sky130_fd_sc_hd__decap_3
XFILLER_41_72 VGND VGND VPWR VPWR sky130_fd_sc_hd__fill_1
XFILLER_10_584 VGND VGND VPWR VPWR sky130_fd_sc_hd__decap_3
XFILLER_41_83 VGND VGND VPWR VPWR sky130_fd_sc_hd__decap_3
XFILLER_10_595 VGND VGND VPWR VPWR sky130_fd_sc_hd__decap_3
XFILLER_115_409 VGND VGND VPWR VPWR sky130_fd_sc_hd__decap_3
XFILLER_6_566 VGND VGND VPWR VPWR sky130_fd_sc_hd__decap_3
XFILLER_108_461 VGND VGND VPWR VPWR sky130_fd_sc_hd__decap_3
XFILLER_51_9 VGND VGND VPWR VPWR sky130_fd_sc_hd__fill_1
XFILLER_108_483 VGND VGND VPWR VPWR sky130_fd_sc_hd__decap_3
XTAP_TAPCELL_ROW_75_1242 VGND VPWR sky130_fd_sc_hd__tapvpwrvgnd_1
XFILLER_123_464 VGND VGND VPWR VPWR sky130_fd_sc_hd__decap_3
XFILLER_111_615 VGND VGND VPWR VPWR sky130_fd_sc_hd__fill_1
XTAP_TAPCELL_ROW_9_382 VGND VPWR sky130_fd_sc_hd__tapvpwrvgnd_1
XFILLER_96_315 VGND VGND VPWR VPWR sky130_fd_sc_hd__decap_3
XFILLER_111_626 VGND VGND VPWR VPWR sky130_fd_sc_hd__decap_3
XFILLER_1_260 VGND VGND VPWR VPWR sky130_fd_sc_hd__decap_3
XFILLER_123_497 VGND VGND VPWR VPWR sky130_fd_sc_hd__decap_3
XFILLER_110_125 VGND VGND VPWR VPWR sky130_fd_sc_hd__decap_3
XFILLER_49_220 VGND VGND VPWR VPWR sky130_fd_sc_hd__decap_3
XFILLER_111_659 VGND VGND VPWR VPWR sky130_fd_sc_hd__decap_3
XFILLER_96_359 VGND VGND VPWR VPWR sky130_fd_sc_hd__decap_3
XFILLER_49_231 VGND VGND VPWR VPWR sky130_fd_sc_hd__decap_3
XFILLER_65_724 VGND VGND VPWR VPWR sky130_fd_sc_hd__decap_3
XFILLER_49_275 VGND VGND VPWR VPWR sky130_fd_sc_hd__decap_3
XFILLER_64_212 VGND VGND VPWR VPWR sky130_fd_sc_hd__decap_3
XFILLER_64_245 VGND VGND VPWR VPWR sky130_fd_sc_hd__decap_3
XFILLER_18_640 VGND VGND VPWR VPWR sky130_fd_sc_hd__decap_3
XFILLER_92_565 VGND VGND VPWR VPWR sky130_fd_sc_hd__decap_3
XFILLER_64_256 VGND VGND VPWR VPWR sky130_fd_sc_hd__decap_3
XFILLER_80_716 VGND VGND VPWR VPWR sky130_fd_sc_hd__decap_3
XFILLER_18_651 VGND VGND VPWR VPWR sky130_fd_sc_hd__decap_3
X_4930_ _6995_/Q _4963_/A _6996_/Q VGND VGND VPWR VPWR _4931_/B sky130_fd_sc_hd__a21oi_2
XFILLER_92_598 VGND VGND VPWR VPWR sky130_fd_sc_hd__decap_3
XFILLER_18_684 VGND VGND VPWR VPWR sky130_fd_sc_hd__decap_3
XFILLER_17_161 VGND VGND VPWR VPWR sky130_fd_sc_hd__decap_3
XTAP_TAPCELL_ROW_86_1382 VGND VPWR sky130_fd_sc_hd__tapvpwrvgnd_1
XFILLER_33_632 VGND VGND VPWR VPWR sky130_fd_sc_hd__decap_3
X_4861_ _6998_/Q _6999_/Q _4912_/A _7000_/Q VGND VGND VPWR VPWR _4862_/B sky130_fd_sc_hd__a31o_2
XFILLER_33_665 VGND VGND VPWR VPWR sky130_fd_sc_hd__decap_3
XFILLER_32_131 VGND VGND VPWR VPWR sky130_fd_sc_hd__decap_3
XFILLER_60_451 VGND VGND VPWR VPWR sky130_fd_sc_hd__decap_3
XFILLER_33_676 VGND VGND VPWR VPWR sky130_fd_sc_hd__decap_3
X_6600_ _6626_/A VGND VGND VPWR VPWR _6600_/Y sky130_fd_sc_hd__inv_2
XFILLER_32_164 VGND VGND VPWR VPWR sky130_fd_sc_hd__decap_3
X_3812_ _3725_/X _3804_/X _3806_/X _3728_/Y _3811_/X VGND VGND VPWR VPWR _3812_/X
+ sky130_fd_sc_hd__a221o_2
XANTENNA_16 _5659_/B VGND VGND VPWR VPWR sky130_fd_sc_hd__diode_2
XPHY_EDGE_ROW_120_Right_120 VGND VGND VPWR VPWR sky130_fd_sc_hd__decap_3
X_4792_ _4997_/A1 _7004_/D _4777_/X _4791_/Y VGND VGND VPWR VPWR _4792_/X sky130_fd_sc_hd__a211o_2
XFILLER_60_495 VGND VGND VPWR VPWR sky130_fd_sc_hd__decap_3
XFILLER_32_197 VGND VGND VPWR VPWR sky130_fd_sc_hd__decap_3
X_3743_ _6848_/Q _3892_/A2 _3893_/A2 _6838_/Q _3742_/X VGND VGND VPWR VPWR _3743_/X
+ sky130_fd_sc_hd__a221o_2
X_6531_ _6591_/A VGND VGND VPWR VPWR _6531_/Y sky130_fd_sc_hd__inv_2
XFILLER_119_715 VGND VGND VPWR VPWR sky130_fd_sc_hd__decap_3
XFILLER_118_236 VGND VGND VPWR VPWR sky130_fd_sc_hd__fill_1
X_3674_ _6806_/Q VGND VGND VPWR VPWR _3674_/Y sky130_fd_sc_hd__inv_2
X_6462_ _6462_/A VGND VGND VPWR VPWR _6462_/Y sky130_fd_sc_hd__inv_2
X_5413_ _5413_/A0 _5107_/X _5427_/S VGND VGND VPWR VPWR _7127_/D sky130_fd_sc_hd__mux2_2
X_6393_ _6553_/A VGND VGND VPWR VPWR _6393_/Y sky130_fd_sc_hd__inv_2
X_5344_ _5344_/A0 _5107_/X _5344_/S VGND VGND VPWR VPWR _7159_/D sky130_fd_sc_hd__mux2_2
XFILLER_114_431 VGND VGND VPWR VPWR sky130_fd_sc_hd__fill_1
XFILLER_102_604 VGND VGND VPWR VPWR sky130_fd_sc_hd__decap_3
XFILLER_87_315 VGND VGND VPWR VPWR sky130_fd_sc_hd__decap_3
XFILLER_87_326 VGND VGND VPWR VPWR sky130_fd_sc_hd__decap_3
XFILLER_114_486 VGND VGND VPWR VPWR sky130_fd_sc_hd__fill_1
XFILLER_102_637 VGND VGND VPWR VPWR sky130_fd_sc_hd__decap_3
XFILLER_87_337 VGND VGND VPWR VPWR sky130_fd_sc_hd__decap_3
XFILLER_102_648 VGND VGND VPWR VPWR sky130_fd_sc_hd__decap_3
X_4226_ _4372_/A _4627_/A VGND VGND VPWR VPWR _4620_/A sky130_fd_sc_hd__nor2_2
X_7014_ _7354_/CLK _7014_/D _6294_/Y VGND VGND VPWR VPWR _7014_/Q sky130_fd_sc_hd__dfrtp_2
XFILLER_101_125 VGND VGND VPWR VPWR sky130_fd_sc_hd__decap_3
XFILLER_87_359 VGND VGND VPWR VPWR sky130_fd_sc_hd__decap_3
XFILLER_101_169 VGND VGND VPWR VPWR sky130_fd_sc_hd__decap_3
XFILLER_56_713 VGND VGND VPWR VPWR sky130_fd_sc_hd__decap_3
X_4157_ _4157_/A _4205_/C VGND VGND VPWR VPWR _4158_/B sky130_fd_sc_hd__nand2_2
XFILLER_110_681 VGND VGND VPWR VPWR sky130_fd_sc_hd__decap_3
X_4088_ _7238_/Q _4414_/A2 _4486_/S _7051_/Q VGND VGND VPWR VPWR _4088_/X sky130_fd_sc_hd__a22o_2
XFILLER_83_576 VGND VGND VPWR VPWR sky130_fd_sc_hd__decap_3
XFILLER_55_267 VGND VGND VPWR VPWR sky130_fd_sc_hd__decap_3
XTAP_TAPCELL_ROW_26_605 VGND VPWR sky130_fd_sc_hd__tapvpwrvgnd_1
XFILLER_71_727 VGND VGND VPWR VPWR sky130_fd_sc_hd__fill_1
XFILLER_43_429 VGND VGND VPWR VPWR sky130_fd_sc_hd__decap_3
XFILLER_36_470 VGND VGND VPWR VPWR sky130_fd_sc_hd__decap_3
XFILLER_24_610 VGND VGND VPWR VPWR sky130_fd_sc_hd__decap_3
XFILLER_24_643 VGND VGND VPWR VPWR sky130_fd_sc_hd__fill_1
XTAP_TAPCELL_ROW_54_969 VGND VPWR sky130_fd_sc_hd__tapvpwrvgnd_1
XFILLER_70_259 VGND VGND VPWR VPWR sky130_fd_sc_hd__fill_1
XFILLER_24_654 VGND VGND VPWR VPWR sky130_fd_sc_hd__decap_3
XFILLER_24_687 VGND VGND VPWR VPWR sky130_fd_sc_hd__decap_3
XFILLER_11_304 VGND VGND VPWR VPWR sky130_fd_sc_hd__decap_3
XFILLER_51_473 VGND VGND VPWR VPWR sky130_fd_sc_hd__decap_3
XFILLER_23_164 VGND VGND VPWR VPWR sky130_fd_sc_hd__decap_3
XFILLER_23_175 VGND VGND VPWR VPWR sky130_fd_sc_hd__decap_3
XFILLER_11_337 VGND VGND VPWR VPWR sky130_fd_sc_hd__decap_3
XFILLER_11_359 VGND VGND VPWR VPWR sky130_fd_sc_hd__decap_3
X_6729_ clkload4/A _6729_/D VGND VGND VPWR VPWR _6729_/Q sky130_fd_sc_hd__dfxtp_2
XFILLER_7_308 VGND VGND VPWR VPWR sky130_fd_sc_hd__decap_3
XFILLER_109_225 VGND VGND VPWR VPWR sky130_fd_sc_hd__decap_3
XFILLER_109_247 VGND VGND VPWR VPWR sky130_fd_sc_hd__decap_3
XFILLER_11_20 VGND VGND VPWR VPWR sky130_fd_sc_hd__fill_1
XFILLER_109_269 VGND VGND VPWR VPWR sky130_fd_sc_hd__decap_3
XFILLER_3_514 VGND VGND VPWR VPWR sky130_fd_sc_hd__decap_3
XFILLER_3_547 VGND VGND VPWR VPWR sky130_fd_sc_hd__decap_3
XTAP_TAPCELL_ROW_111_1707 VGND VPWR sky130_fd_sc_hd__tapvpwrvgnd_1
XFILLER_11_97 VGND VGND VPWR VPWR sky130_fd_sc_hd__decap_3
XFILLER_87_24 VGND VGND VPWR VPWR sky130_fd_sc_hd__decap_3
XFILLER_78_315 VGND VGND VPWR VPWR sky130_fd_sc_hd__decap_3
XFILLER_120_401 VGND VGND VPWR VPWR sky130_fd_sc_hd__decap_3
XTAP_TAPCELL_ROW_6_341 VGND VPWR sky130_fd_sc_hd__tapvpwrvgnd_1
XTAP_TAPCELL_ROW_70_1172 VGND VPWR sky130_fd_sc_hd__tapvpwrvgnd_1
XFILLER_93_318 VGND VGND VPWR VPWR sky130_fd_sc_hd__decap_3
XTAP_TAPCELL_ROW_70_1183 VGND VPWR sky130_fd_sc_hd__tapvpwrvgnd_1
XFILLER_120_489 VGND VGND VPWR VPWR sky130_fd_sc_hd__decap_3
XFILLER_47_724 VGND VGND VPWR VPWR sky130_fd_sc_hd__decap_3
XFILLER_74_521 VGND VGND VPWR VPWR sky130_fd_sc_hd__decap_3
XFILLER_46_234 VGND VGND VPWR VPWR sky130_fd_sc_hd__decap_3
XFILLER_100_180 VGND VGND VPWR VPWR sky130_fd_sc_hd__decap_3
XFILLER_46_256 VGND VGND VPWR VPWR sky130_fd_sc_hd__decap_3
XFILLER_62_716 VGND VGND VPWR VPWR sky130_fd_sc_hd__decap_3
XFILLER_74_598 VGND VGND VPWR VPWR sky130_fd_sc_hd__decap_3
XFILLER_61_215 VGND VGND VPWR VPWR sky130_fd_sc_hd__decap_3
XFILLER_46_289 VGND VGND VPWR VPWR sky130_fd_sc_hd__decap_3
XFILLER_61_237 VGND VGND VPWR VPWR sky130_fd_sc_hd__decap_3
XFILLER_15_632 VGND VGND VPWR VPWR sky130_fd_sc_hd__decap_3
XFILLER_36_94 VGND VGND VPWR VPWR sky130_fd_sc_hd__fill_1
XTAP_TAPCELL_ROW_122_1847 VGND VPWR sky130_fd_sc_hd__tapvpwrvgnd_1
XFILLER_61_259 VGND VGND VPWR VPWR sky130_fd_sc_hd__decap_3
XFILLER_42_440 VGND VGND VPWR VPWR sky130_fd_sc_hd__decap_3
XTAP_TAPCELL_ROW_122_1858 VGND VPWR sky130_fd_sc_hd__tapvpwrvgnd_1
XFILLER_15_665 VGND VGND VPWR VPWR sky130_fd_sc_hd__decap_3
XFILLER_15_676 VGND VGND VPWR VPWR sky130_fd_sc_hd__decap_3
XFILLER_99_9 VGND VGND VPWR VPWR sky130_fd_sc_hd__fill_1
XFILLER_14_153 VGND VGND VPWR VPWR sky130_fd_sc_hd__decap_3
XFILLER_30_613 VGND VGND VPWR VPWR sky130_fd_sc_hd__decap_3
XFILLER_14_197 VGND VGND VPWR VPWR sky130_fd_sc_hd__decap_3
XFILLER_30_657 VGND VGND VPWR VPWR sky130_fd_sc_hd__decap_3
XFILLER_116_707 VGND VGND VPWR VPWR sky130_fd_sc_hd__decap_3
XFILLER_6_341 VGND VGND VPWR VPWR sky130_fd_sc_hd__fill_1
XFILLER_10_392 VGND VGND VPWR VPWR sky130_fd_sc_hd__decap_3
Xhold809 _6855_/Q VGND VGND VPWR VPWR _6855_/D sky130_fd_sc_hd__dlygate4sd3_1
XFILLER_6_363 VGND VGND VPWR VPWR sky130_fd_sc_hd__fill_1
XFILLER_6_396 VGND VGND VPWR VPWR sky130_fd_sc_hd__fill_1
X_3390_ _7155_/Q _3366_/X _3379_/X _3389_/X VGND VGND VPWR VPWR _3390_/X sky130_fd_sc_hd__a211o_2
XFILLER_96_101 VGND VGND VPWR VPWR sky130_fd_sc_hd__fill_1
XFILLER_69_315 VGND VGND VPWR VPWR sky130_fd_sc_hd__fill_2
XFILLER_97_635 VGND VGND VPWR VPWR sky130_fd_sc_hd__decap_3
XFILLER_69_337 VGND VGND VPWR VPWR sky130_fd_sc_hd__decap_3
X_5060_ _5581_/S _5045_/X _5059_/X _4467_/B VGND VGND VPWR VPWR _5060_/X sky130_fd_sc_hd__a22o_2
XFILLER_111_445 VGND VGND VPWR VPWR sky130_fd_sc_hd__decap_3
XFILLER_97_668 VGND VGND VPWR VPWR sky130_fd_sc_hd__decap_3
XFILLER_97_679 VGND VGND VPWR VPWR sky130_fd_sc_hd__decap_3
XFILLER_96_167 VGND VGND VPWR VPWR sky130_fd_sc_hd__decap_3
X_4011_ _7342_/Q _3943_/S _4419_/B1 _7374_/Q _4429_/C1 VGND VGND VPWR VPWR _4011_/X
+ sky130_fd_sc_hd__a221o_2
XFILLER_84_318 VGND VGND VPWR VPWR sky130_fd_sc_hd__decap_3
XFILLER_38_713 VGND VGND VPWR VPWR sky130_fd_sc_hd__decap_3
XTAP_TAPCELL_ROW_88_1411 VGND VPWR sky130_fd_sc_hd__tapvpwrvgnd_1
XFILLER_96_189 VGND VGND VPWR VPWR sky130_fd_sc_hd__decap_3
XFILLER_65_532 VGND VGND VPWR VPWR sky130_fd_sc_hd__fill_1
XFILLER_37_223 VGND VGND VPWR VPWR sky130_fd_sc_hd__fill_1
XFILLER_53_727 VGND VGND VPWR VPWR sky130_fd_sc_hd__fill_1
XFILLER_65_598 VGND VGND VPWR VPWR sky130_fd_sc_hd__decap_3
XFILLER_92_395 VGND VGND VPWR VPWR sky130_fd_sc_hd__decap_3
X_4913_ _5657_/B _3762_/X _4910_/Y _6997_/D _5040_/S VGND VGND VPWR VPWR _4913_/X
+ sky130_fd_sc_hd__o32a_2
XTAP_TAPCELL_ROW_51_928 VGND VPWR sky130_fd_sc_hd__tapvpwrvgnd_1
XFILLER_33_473 VGND VGND VPWR VPWR sky130_fd_sc_hd__decap_3
XFILLER_21_613 VGND VGND VPWR VPWR sky130_fd_sc_hd__decap_3
XFILLER_33_484 VGND VGND VPWR VPWR sky130_fd_sc_hd__decap_3
X_4844_ _4633_/A _4111_/B _4842_/X _4843_/Y _4829_/A VGND VGND VPWR VPWR _4855_/A
+ sky130_fd_sc_hd__a311oi_2
XFILLER_21_635 VGND VGND VPWR VPWR sky130_fd_sc_hd__decap_3
XFILLER_60_292 VGND VGND VPWR VPWR sky130_fd_sc_hd__decap_3
XFILLER_21_668 VGND VGND VPWR VPWR sky130_fd_sc_hd__decap_3
XFILLER_21_679 VGND VGND VPWR VPWR sky130_fd_sc_hd__decap_3
X_4775_ _4775_/A _4775_/B VGND VGND VPWR VPWR _7004_/D sky130_fd_sc_hd__nor2_2
XFILLER_20_156 VGND VGND VPWR VPWR sky130_fd_sc_hd__decap_3
XFILLER_119_523 VGND VGND VPWR VPWR sky130_fd_sc_hd__decap_3
XTAP_TAPCELL_ROW_31_674 VGND VPWR sky130_fd_sc_hd__tapvpwrvgnd_1
XTAP_TAPCELL_ROW_99_1551 VGND VPWR sky130_fd_sc_hd__tapvpwrvgnd_1
XFILLER_20_178 VGND VGND VPWR VPWR sky130_fd_sc_hd__decap_3
X_6514_ _6610_/A VGND VGND VPWR VPWR _6514_/Y sky130_fd_sc_hd__inv_2
XFILLER_20_189 VGND VGND VPWR VPWR sky130_fd_sc_hd__decap_3
X_3726_ _3714_/X _3721_/X _3724_/X _3725_/X VGND VGND VPWR VPWR _3726_/X sky130_fd_sc_hd__a22o_2
XFILLER_119_556 VGND VGND VPWR VPWR sky130_fd_sc_hd__decap_3
XFILLER_119_567 VGND VGND VPWR VPWR sky130_fd_sc_hd__decap_3
XFILLER_107_718 VGND VGND VPWR VPWR sky130_fd_sc_hd__decap_3
XFILLER_107_729 VGND VGND VPWR VPWR sky130_fd_sc_hd__decap_3
XFILLER_106_206 VGND VGND VPWR VPWR sky130_fd_sc_hd__decap_3
X_6445_ _6638_/A VGND VGND VPWR VPWR _6445_/Y sky130_fd_sc_hd__inv_2
X_6376_ _6568_/A VGND VGND VPWR VPWR _6376_/Y sky130_fd_sc_hd__inv_2
XFILLER_88_613 VGND VGND VPWR VPWR sky130_fd_sc_hd__decap_3
X_5327_ _5327_/A0 _4978_/X _5340_/S VGND VGND VPWR VPWR _7167_/D sky130_fd_sc_hd__mux2_2
XFILLER_102_401 VGND VGND VPWR VPWR sky130_fd_sc_hd__decap_3
XFILLER_0_539 VGND VGND VPWR VPWR sky130_fd_sc_hd__decap_3
XFILLER_88_657 VGND VGND VPWR VPWR sky130_fd_sc_hd__decap_3
XFILLER_87_134 VGND VGND VPWR VPWR sky130_fd_sc_hd__decap_3
X_5258_ _5258_/A0 _4945_/X _5258_/S VGND VGND VPWR VPWR _7201_/D sky130_fd_sc_hd__mux2_2
XFILLER_102_467 VGND VGND VPWR VPWR sky130_fd_sc_hd__decap_3
XTAP_TAPCELL_ROW_3_300 VGND VPWR sky130_fd_sc_hd__tapvpwrvgnd_1
XFILLER_75_307 VGND VGND VPWR VPWR sky130_fd_sc_hd__decap_3
XTAP_TAPCELL_ROW_3_311 VGND VPWR sky130_fd_sc_hd__tapvpwrvgnd_1
XFILLER_87_178 VGND VGND VPWR VPWR sky130_fd_sc_hd__decap_3
X_4209_ _4633_/A _4903_/A _4845_/A _4890_/B VGND VGND VPWR VPWR _4384_/A sky130_fd_sc_hd__and4_2
XFILLER_75_329 VGND VGND VPWR VPWR sky130_fd_sc_hd__fill_2
XFILLER_29_724 VGND VGND VPWR VPWR sky130_fd_sc_hd__decap_3
XFILLER_96_690 VGND VGND VPWR VPWR sky130_fd_sc_hd__decap_3
XFILLER_28_245 VGND VGND VPWR VPWR sky130_fd_sc_hd__decap_3
XFILLER_113_33 VGND VGND VPWR VPWR sky130_fd_sc_hd__decap_3
XFILLER_83_340 VGND VGND VPWR VPWR sky130_fd_sc_hd__decap_3
XFILLER_28_256 VGND VGND VPWR VPWR sky130_fd_sc_hd__decap_3
XFILLER_73_15 VGND VGND VPWR VPWR sky130_fd_sc_hd__decap_3
XFILLER_44_716 VGND VGND VPWR VPWR sky130_fd_sc_hd__decap_3
XFILLER_16_407 VGND VGND VPWR VPWR sky130_fd_sc_hd__fill_1
XFILLER_113_66 VGND VGND VPWR VPWR sky130_fd_sc_hd__decap_3
XTAP_TAPCELL_ROW_39_774 VGND VPWR sky130_fd_sc_hd__tapvpwrvgnd_1
XFILLER_83_373 VGND VGND VPWR VPWR sky130_fd_sc_hd__fill_1
XFILLER_71_513 VGND VGND VPWR VPWR sky130_fd_sc_hd__decap_3
XFILLER_28_289 VGND VGND VPWR VPWR sky130_fd_sc_hd__decap_3
XFILLER_113_99 VGND VGND VPWR VPWR sky130_fd_sc_hd__fill_2
XFILLER_12_613 VGND VGND VPWR VPWR sky130_fd_sc_hd__decap_3
XFILLER_51_270 VGND VGND VPWR VPWR sky130_fd_sc_hd__decap_3
XFILLER_51_281 VGND VGND VPWR VPWR sky130_fd_sc_hd__decap_3
XFILLER_12_657 VGND VGND VPWR VPWR sky130_fd_sc_hd__decap_3
XFILLER_8_628 VGND VGND VPWR VPWR sky130_fd_sc_hd__decap_3
XFILLER_11_156 VGND VGND VPWR VPWR sky130_fd_sc_hd__decap_3
XFILLER_11_178 VGND VGND VPWR VPWR sky130_fd_sc_hd__fill_1
XFILLER_20_690 VGND VGND VPWR VPWR sky130_fd_sc_hd__decap_3
XFILLER_22_85 VGND VGND VPWR VPWR sky130_fd_sc_hd__decap_3
XTAP_TAPCELL_ROW_59_1034 VGND VPWR sky130_fd_sc_hd__tapvpwrvgnd_1
XFILLER_98_56 VGND VGND VPWR VPWR sky130_fd_sc_hd__decap_3
XTAP_TAPCELL_ROW_72_1201 VGND VPWR sky130_fd_sc_hd__tapvpwrvgnd_1
XFILLER_105_250 VGND VGND VPWR VPWR sky130_fd_sc_hd__decap_3
XFILLER_3_388 VGND VGND VPWR VPWR sky130_fd_sc_hd__decap_3
XFILLER_121_721 VGND VGND VPWR VPWR sky130_fd_sc_hd__decap_3
XFILLER_79_635 VGND VGND VPWR VPWR sky130_fd_sc_hd__decap_3
XFILLER_78_112 VGND VGND VPWR VPWR sky130_fd_sc_hd__decap_3
XFILLER_121_732 VGND VGND VPWR VPWR sky130_fd_sc_hd__decap_3
XFILLER_79_668 VGND VGND VPWR VPWR sky130_fd_sc_hd__decap_3
XFILLER_79_679 VGND VGND VPWR VPWR sky130_fd_sc_hd__decap_3
XFILLER_94_616 VGND VGND VPWR VPWR sky130_fd_sc_hd__decap_3
XFILLER_120_253 VGND VGND VPWR VPWR sky130_fd_sc_hd__decap_3
XFILLER_66_318 VGND VGND VPWR VPWR sky130_fd_sc_hd__decap_3
XFILLER_19_212 VGND VGND VPWR VPWR sky130_fd_sc_hd__decap_3
XFILLER_47_60 VGND VGND VPWR VPWR sky130_fd_sc_hd__decap_3
XFILLER_74_351 VGND VGND VPWR VPWR sky130_fd_sc_hd__decap_3
XFILLER_47_576 VGND VGND VPWR VPWR sky130_fd_sc_hd__decap_3
XFILLER_35_727 VGND VGND VPWR VPWR sky130_fd_sc_hd__fill_1
XFILLER_19_278 VGND VGND VPWR VPWR sky130_fd_sc_hd__fill_2
XFILLER_34_204 VGND VGND VPWR VPWR sky130_fd_sc_hd__decap_3
XFILLER_19_289 VGND VGND VPWR VPWR sky130_fd_sc_hd__decap_3
XFILLER_34_237 VGND VGND VPWR VPWR sky130_fd_sc_hd__fill_2
XFILLER_62_557 VGND VGND VPWR VPWR sky130_fd_sc_hd__decap_3
XTAP_TAPCELL_ROW_83_1341 VGND VPWR sky130_fd_sc_hd__tapvpwrvgnd_1
XFILLER_34_259 VGND VGND VPWR VPWR sky130_fd_sc_hd__decap_3
XFILLER_50_719 VGND VGND VPWR VPWR sky130_fd_sc_hd__decap_3
XTAP_TAPCELL_ROW_83_1352 VGND VPWR sky130_fd_sc_hd__tapvpwrvgnd_1
XFILLER_63_81 VGND VGND VPWR VPWR sky130_fd_sc_hd__decap_3
XFILLER_15_484 VGND VGND VPWR VPWR sky130_fd_sc_hd__decap_3
XFILLER_30_421 VGND VGND VPWR VPWR sky130_fd_sc_hd__decap_3
XFILLER_8_54 VGND VGND VPWR VPWR sky130_fd_sc_hd__decap_3
XFILLER_7_650 VGND VGND VPWR VPWR sky130_fd_sc_hd__decap_3
XFILLER_116_515 VGND VGND VPWR VPWR sky130_fd_sc_hd__decap_3
X_4491_ _7334_/Q _7302_/Q _4497_/S VGND VGND VPWR VPWR _7334_/D sky130_fd_sc_hd__mux2_2
Xhold606 _6923_/Q VGND VGND VPWR VPWR _6923_/D sky130_fd_sc_hd__dlygate4sd3_1
Xhold617 _6752_/Q VGND VGND VPWR VPWR _6752_/D sky130_fd_sc_hd__dlygate4sd3_1
XFILLER_7_694 VGND VGND VPWR VPWR sky130_fd_sc_hd__decap_3
Xhold628 _6725_/Q VGND VGND VPWR VPWR _6725_/D sky130_fd_sc_hd__dlygate4sd3_1
XFILLER_116_548 VGND VGND VPWR VPWR sky130_fd_sc_hd__decap_3
X_3442_ _3442_/A _3442_/B VGND VGND VPWR VPWR _4394_/A sky130_fd_sc_hd__nand2_2
Xhold639 _6862_/Q VGND VGND VPWR VPWR _6862_/D sky130_fd_sc_hd__dlygate4sd3_1
XFILLER_103_209 VGND VGND VPWR VPWR sky130_fd_sc_hd__decap_3
XFILLER_112_710 VGND VGND VPWR VPWR sky130_fd_sc_hd__decap_3
XTAP_TAPCELL_ROW_94_1492 VGND VPWR sky130_fd_sc_hd__tapvpwrvgnd_1
X_3373_ _3560_/B _3370_/Y _3977_/S VGND VGND VPWR VPWR _3429_/A sky130_fd_sc_hd__a21o_2
X_5112_ _4292_/A _3594_/B _4295_/X VGND VGND VPWR VPWR _5113_/B sky130_fd_sc_hd__a21oi_2
XFILLER_69_167 VGND VGND VPWR VPWR sky130_fd_sc_hd__fill_1
XFILLER_111_253 VGND VGND VPWR VPWR sky130_fd_sc_hd__decap_3
X_5043_ _6988_/Q _5066_/A VGND VGND VPWR VPWR _5044_/B sky130_fd_sc_hd__nor2_2
XFILLER_84_104 VGND VGND VPWR VPWR sky130_fd_sc_hd__decap_3
XFILLER_69_178 VGND VGND VPWR VPWR sky130_fd_sc_hd__decap_3
XFILLER_85_638 VGND VGND VPWR VPWR sky130_fd_sc_hd__decap_3
XFILLER_78_690 VGND VGND VPWR VPWR sky130_fd_sc_hd__decap_3
XFILLER_84_159 VGND VGND VPWR VPWR sky130_fd_sc_hd__fill_2
XFILLER_65_340 VGND VGND VPWR VPWR sky130_fd_sc_hd__decap_3
XFILLER_26_716 VGND VGND VPWR VPWR sky130_fd_sc_hd__decap_3
XFILLER_93_671 VGND VGND VPWR VPWR sky130_fd_sc_hd__fill_1
XFILLER_93_682 VGND VGND VPWR VPWR sky130_fd_sc_hd__decap_3
XFILLER_38_598 VGND VGND VPWR VPWR sky130_fd_sc_hd__decap_3
XTAP_TAPCELL_ROW_36_733 VGND VPWR sky130_fd_sc_hd__tapvpwrvgnd_1
X_6994_ _7362_/CLK _6994_/D _6274_/Y VGND VGND VPWR VPWR _6994_/Q sky130_fd_sc_hd__dfrtp_2
XFILLER_80_321 VGND VGND VPWR VPWR sky130_fd_sc_hd__decap_3
XFILLER_92_192 VGND VGND VPWR VPWR sky130_fd_sc_hd__decap_3
XFILLER_80_365 VGND VGND VPWR VPWR sky130_fd_sc_hd__fill_1
XFILLER_40_207 VGND VGND VPWR VPWR sky130_fd_sc_hd__decap_3
XFILLER_80_387 VGND VGND VPWR VPWR sky130_fd_sc_hd__decap_3
XFILLER_40_229 VGND VGND VPWR VPWR sky130_fd_sc_hd__decap_3
XFILLER_21_432 VGND VGND VPWR VPWR sky130_fd_sc_hd__decap_3
X_4827_ _4827_/A _4827_/B VGND VGND VPWR VPWR _4827_/X sky130_fd_sc_hd__xor2_2
X_4758_ _7004_/Q _4804_/A VGND VGND VPWR VPWR _4777_/B sky130_fd_sc_hd__nand2_2
XFILLER_5_609 VGND VGND VPWR VPWR sky130_fd_sc_hd__decap_3
X_3709_ _3682_/A _3708_/X _4791_/A1 VGND VGND VPWR VPWR _3709_/X sky130_fd_sc_hd__a21o_2
XFILLER_107_526 VGND VGND VPWR VPWR sky130_fd_sc_hd__decap_3
X_4689_ _7002_/Q _4834_/A _4688_/X _7003_/Q VGND VGND VPWR VPWR _4804_/A sky130_fd_sc_hd__o211a_2
XFILLER_107_559 VGND VGND VPWR VPWR sky130_fd_sc_hd__fill_1
X_6428_ _6620_/A VGND VGND VPWR VPWR _6428_/Y sky130_fd_sc_hd__inv_2
XFILLER_108_44 VGND VGND VPWR VPWR sky130_fd_sc_hd__decap_3
XFILLER_122_507 VGND VGND VPWR VPWR sky130_fd_sc_hd__decap_3
XFILLER_88_410 VGND VGND VPWR VPWR sky130_fd_sc_hd__decap_3
XFILLER_68_26 VGND VGND VPWR VPWR sky130_fd_sc_hd__fill_2
XFILLER_115_570 VGND VGND VPWR VPWR sky130_fd_sc_hd__decap_3
X_6359_ _6363_/A VGND VGND VPWR VPWR _6359_/Y sky130_fd_sc_hd__inv_2
XFILLER_103_721 VGND VGND VPWR VPWR sky130_fd_sc_hd__decap_3
XFILLER_88_421 VGND VGND VPWR VPWR sky130_fd_sc_hd__decap_3
XFILLER_103_732 VGND VGND VPWR VPWR sky130_fd_sc_hd__decap_3
XFILLER_76_616 VGND VGND VPWR VPWR sky130_fd_sc_hd__decap_3
XFILLER_88_487 VGND VGND VPWR VPWR sky130_fd_sc_hd__decap_3
XFILLER_102_264 VGND VGND VPWR VPWR sky130_fd_sc_hd__fill_1
XFILLER_102_286 VGND VGND VPWR VPWR sky130_fd_sc_hd__decap_3
XFILLER_75_159 VGND VGND VPWR VPWR sky130_fd_sc_hd__decap_3
XFILLER_84_47 VGND VGND VPWR VPWR sky130_fd_sc_hd__fill_1
XFILLER_84_660 VGND VGND VPWR VPWR sky130_fd_sc_hd__decap_3
XFILLER_44_502 VGND VGND VPWR VPWR sky130_fd_sc_hd__decap_3
XFILLER_17_727 VGND VGND VPWR VPWR sky130_fd_sc_hd__fill_1
XFILLER_16_204 VGND VGND VPWR VPWR sky130_fd_sc_hd__decap_3
XFILLER_29_598 VGND VGND VPWR VPWR sky130_fd_sc_hd__decap_3
XFILLER_84_693 VGND VGND VPWR VPWR sky130_fd_sc_hd__decap_3
XTAP_TAPCELL_ROW_106_1639 VGND VPWR sky130_fd_sc_hd__tapvpwrvgnd_1
XFILLER_44_568 VGND VGND VPWR VPWR sky130_fd_sc_hd__decap_3
XFILLER_16_259 VGND VGND VPWR VPWR sky130_fd_sc_hd__decap_3
XFILLER_32_719 VGND VGND VPWR VPWR sky130_fd_sc_hd__decap_3
XFILLER_71_387 VGND VGND VPWR VPWR sky130_fd_sc_hd__decap_3
XFILLER_12_421 VGND VGND VPWR VPWR sky130_fd_sc_hd__decap_3
XTAP_TAPCELL_ROW_14_449 VGND VPWR sky130_fd_sc_hd__tapvpwrvgnd_1
XFILLER_24_292 VGND VGND VPWR VPWR sky130_fd_sc_hd__decap_3
XFILLER_12_443 VGND VGND VPWR VPWR sky130_fd_sc_hd__decap_3
XFILLER_8_447 VGND VGND VPWR VPWR sky130_fd_sc_hd__decap_3
XFILLER_4_631 VGND VGND VPWR VPWR sky130_fd_sc_hd__decap_3
XFILLER_98_218 VGND VGND VPWR VPWR sky130_fd_sc_hd__decap_3
XFILLER_4_675 VGND VGND VPWR VPWR sky130_fd_sc_hd__decap_3
XFILLER_113_529 VGND VGND VPWR VPWR sky130_fd_sc_hd__decap_3
XFILLER_106_581 VGND VGND VPWR VPWR sky130_fd_sc_hd__decap_3
XFILLER_106_592 VGND VGND VPWR VPWR sky130_fd_sc_hd__decap_3
XFILLER_3_196 VGND VGND VPWR VPWR sky130_fd_sc_hd__decap_3
XFILLER_79_476 VGND VGND VPWR VPWR sky130_fd_sc_hd__decap_3
XFILLER_39_307 VGND VGND VPWR VPWR sky130_fd_sc_hd__decap_3
XFILLER_121_573 VGND VGND VPWR VPWR sky130_fd_sc_hd__decap_3
XFILLER_67_638 VGND VGND VPWR VPWR sky130_fd_sc_hd__decap_3
XFILLER_39_329 VGND VGND VPWR VPWR sky130_fd_sc_hd__decap_3
XFILLER_94_424 VGND VGND VPWR VPWR sky130_fd_sc_hd__decap_3
XFILLER_94_457 VGND VGND VPWR VPWR sky130_fd_sc_hd__decap_3
XFILLER_12_6 VGND VGND VPWR VPWR sky130_fd_sc_hd__fill_2
XFILLER_82_619 VGND VGND VPWR VPWR sky130_fd_sc_hd__decap_3
XFILLER_47_340 VGND VGND VPWR VPWR sky130_fd_sc_hd__decap_3
XFILLER_75_671 VGND VGND VPWR VPWR sky130_fd_sc_hd__fill_1
XFILLER_75_682 VGND VGND VPWR VPWR sky130_fd_sc_hd__decap_3
XFILLER_62_321 VGND VGND VPWR VPWR sky130_fd_sc_hd__decap_3
XFILLER_62_343 VGND VGND VPWR VPWR sky130_fd_sc_hd__fill_2
XFILLER_90_663 VGND VGND VPWR VPWR sky130_fd_sc_hd__decap_3
XFILLER_62_354 VGND VGND VPWR VPWR sky130_fd_sc_hd__decap_3
XFILLER_62_365 VGND VGND VPWR VPWR sky130_fd_sc_hd__fill_1
X_3991_ _3991_/A _3991_/B VGND VGND VPWR VPWR _3991_/X sky130_fd_sc_hd__or2_2
XFILLER_62_376 VGND VGND VPWR VPWR sky130_fd_sc_hd__fill_1
XFILLER_22_207 VGND VGND VPWR VPWR sky130_fd_sc_hd__decap_3
XFILLER_90_696 VGND VGND VPWR VPWR sky130_fd_sc_hd__decap_3
XFILLER_95_3 VGND VGND VPWR VPWR sky130_fd_sc_hd__decap_3
XFILLER_43_590 VGND VGND VPWR VPWR sky130_fd_sc_hd__decap_3
XFILLER_15_281 VGND VGND VPWR VPWR sky130_fd_sc_hd__fill_1
X_5661_ _5661_/A _5661_/B _5661_/C _5661_/D VGND VGND VPWR VPWR _5661_/X sky130_fd_sc_hd__and4_2
XFILLER_30_262 VGND VGND VPWR VPWR sky130_fd_sc_hd__decap_3
X_7400_ _7404_/CLK _7400_/D _6680_/Y VGND VGND VPWR VPWR _7400_/Q sky130_fd_sc_hd__dfrtp_2
XFILLER_90_90 VGND VGND VPWR VPWR sky130_fd_sc_hd__fill_1
X_4612_ _4612_/A _4612_/B VGND VGND VPWR VPWR _5114_/B sky130_fd_sc_hd__nor2_2
XTAP_TAPCELL_ROW_96_1510 VGND VPWR sky130_fd_sc_hd__tapvpwrvgnd_1
XTAP_TAPCELL_ROW_96_1521 VGND VPWR sky130_fd_sc_hd__tapvpwrvgnd_1
X_7331_ _7365_/CLK _7331_/D _6611_/Y VGND VGND VPWR VPWR _7331_/Q sky130_fd_sc_hd__dfrtp_2
XFILLER_116_312 VGND VGND VPWR VPWR sky130_fd_sc_hd__fill_2
XFILLER_116_345 VGND VGND VPWR VPWR sky130_fd_sc_hd__fill_2
X_7262_ _7362_/CLK _7262_/D _6542_/Y VGND VGND VPWR VPWR _7262_/Q sky130_fd_sc_hd__dfrtp_2
X_4474_ _4474_/A0 _7310_/Q _4486_/S VGND VGND VPWR VPWR _4474_/X sky130_fd_sc_hd__mux2_2
XFILLER_89_207 VGND VGND VPWR VPWR sky130_fd_sc_hd__decap_3
X_3425_ _3589_/A _4376_/A _3589_/B _3590_/C VGND VGND VPWR VPWR _3527_/A sky130_fd_sc_hd__o31a_2
X_7193_ _7356_/CLK _7193_/D _6473_/Y VGND VGND VPWR VPWR _7193_/Q sky130_fd_sc_hd__dfrtp_2
X_3356_ _5118_/D _3354_/X _3355_/Y _5129_/A VGND VGND VPWR VPWR _4537_/B sky130_fd_sc_hd__a22o_2
XFILLER_58_605 VGND VGND VPWR VPWR sky130_fd_sc_hd__decap_3
XFILLER_112_551 VGND VGND VPWR VPWR sky130_fd_sc_hd__decap_3
XFILLER_85_402 VGND VGND VPWR VPWR sky130_fd_sc_hd__decap_3
XFILLER_38_29 VGND VGND VPWR VPWR sky130_fd_sc_hd__decap_3
XFILLER_100_713 VGND VGND VPWR VPWR sky130_fd_sc_hd__decap_3
Xhold1103 _7140_/Q VGND VGND VPWR VPWR _5386_/A0 sky130_fd_sc_hd__dlygate4sd3_1
XFILLER_58_638 VGND VGND VPWR VPWR sky130_fd_sc_hd__decap_3
XFILLER_112_584 VGND VGND VPWR VPWR sky130_fd_sc_hd__decap_3
Xhold1114 _7234_/Q VGND VGND VPWR VPWR _5188_/A sky130_fd_sc_hd__dlygate4sd3_1
XFILLER_97_284 VGND VGND VPWR VPWR sky130_fd_sc_hd__decap_3
XFILLER_85_435 VGND VGND VPWR VPWR sky130_fd_sc_hd__decap_3
XFILLER_112_595 VGND VGND VPWR VPWR sky130_fd_sc_hd__decap_3
Xhold1125 _7284_/Q VGND VGND VPWR VPWR _4593_/A sky130_fd_sc_hd__dlygate4sd3_1
XFILLER_57_137 VGND VGND VPWR VPWR sky130_fd_sc_hd__fill_1
Xhold1136 _7312_/Q VGND VGND VPWR VPWR _4534_/A0 sky130_fd_sc_hd__dlygate4sd3_1
Xhold1147 _7160_/Q VGND VGND VPWR VPWR _5342_/A0 sky130_fd_sc_hd__dlygate4sd3_1
X_5026_ _5026_/A _5026_/B VGND VGND VPWR VPWR _6990_/D sky130_fd_sc_hd__nor2_2
Xhold1158 _7175_/Q VGND VGND VPWR VPWR _5310_/A0 sky130_fd_sc_hd__dlygate4sd3_1
XFILLER_85_468 VGND VGND VPWR VPWR sky130_fd_sc_hd__decap_3
XFILLER_73_608 VGND VGND VPWR VPWR sky130_fd_sc_hd__decap_3
Xhold1169 _7405_/Q VGND VGND VPWR VPWR _3671_/A1 sky130_fd_sc_hd__dlygate4sd3_1
XFILLER_66_660 VGND VGND VPWR VPWR sky130_fd_sc_hd__decap_3
XFILLER_38_351 VGND VGND VPWR VPWR sky130_fd_sc_hd__decap_3
XFILLER_72_118 VGND VGND VPWR VPWR sky130_fd_sc_hd__decap_3
XFILLER_66_693 VGND VGND VPWR VPWR sky130_fd_sc_hd__decap_3
XFILLER_81_641 VGND VGND VPWR VPWR sky130_fd_sc_hd__decap_3
XFILLER_53_354 VGND VGND VPWR VPWR sky130_fd_sc_hd__fill_2
XFILLER_41_505 VGND VGND VPWR VPWR sky130_fd_sc_hd__decap_3
XFILLER_14_719 VGND VGND VPWR VPWR sky130_fd_sc_hd__decap_3
X_6977_ _7380_/CLK _6977_/D VGND VGND VPWR VPWR _6977_/Q sky130_fd_sc_hd__dfxtp_2
XFILLER_81_685 VGND VGND VPWR VPWR sky130_fd_sc_hd__decap_3
XFILLER_110_12 VGND VGND VPWR VPWR sky130_fd_sc_hd__decap_3
XFILLER_80_195 VGND VGND VPWR VPWR sky130_fd_sc_hd__fill_1
XFILLER_110_56 VGND VGND VPWR VPWR sky130_fd_sc_hd__decap_3
XFILLER_70_27 VGND VGND VPWR VPWR sky130_fd_sc_hd__fill_1
XFILLER_21_240 VGND VGND VPWR VPWR sky130_fd_sc_hd__decap_3
XTAP_TAPCELL_ROW_11_408 VGND VPWR sky130_fd_sc_hd__tapvpwrvgnd_1
XFILLER_70_38 VGND VGND VPWR VPWR sky130_fd_sc_hd__decap_3
XFILLER_21_273 VGND VGND VPWR VPWR sky130_fd_sc_hd__decap_3
XFILLER_21_284 VGND VGND VPWR VPWR sky130_fd_sc_hd__decap_3
XFILLER_119_21 VGND VGND VPWR VPWR sky130_fd_sc_hd__decap_3
XFILLER_107_301 VGND VGND VPWR VPWR sky130_fd_sc_hd__fill_1
XFILLER_119_54 VGND VGND VPWR VPWR sky130_fd_sc_hd__fill_2
XFILLER_119_172 VGND VGND VPWR VPWR sky130_fd_sc_hd__fill_1
XFILLER_5_439 VGND VGND VPWR VPWR sky130_fd_sc_hd__decap_3
XFILLER_79_36 VGND VGND VPWR VPWR sky130_fd_sc_hd__decap_3
XFILLER_119_87 VGND VGND VPWR VPWR sky130_fd_sc_hd__decap_3
XFILLER_107_356 VGND VGND VPWR VPWR sky130_fd_sc_hd__decap_3
XFILLER_79_69 VGND VGND VPWR VPWR sky130_fd_sc_hd__decap_3
XFILLER_1_612 VGND VGND VPWR VPWR sky130_fd_sc_hd__fill_1
Xhold970 _7393_/Q VGND VGND VPWR VPWR hold970/X sky130_fd_sc_hd__dlygate4sd3_1
XFILLER_1_623 VGND VGND VPWR VPWR sky130_fd_sc_hd__decap_3
XFILLER_122_326 VGND VGND VPWR VPWR sky130_fd_sc_hd__fill_1
Xhold981 _7011_/Q VGND VGND VPWR VPWR _5634_/A sky130_fd_sc_hd__dlygate4sd3_1
Xhold992 _7206_/Q VGND VGND VPWR VPWR hold992/X sky130_fd_sc_hd__dlygate4sd3_1
XFILLER_1_656 VGND VGND VPWR VPWR sky130_fd_sc_hd__decap_3
XFILLER_76_413 VGND VGND VPWR VPWR sky130_fd_sc_hd__decap_3
XFILLER_103_573 VGND VGND VPWR VPWR sky130_fd_sc_hd__decap_3
XFILLER_0_177 VGND VGND VPWR VPWR sky130_fd_sc_hd__decap_3
XFILLER_76_424 VGND VGND VPWR VPWR sky130_fd_sc_hd__decap_3
XFILLER_49_638 VGND VGND VPWR VPWR sky130_fd_sc_hd__decap_3
XFILLER_76_446 VGND VGND VPWR VPWR sky130_fd_sc_hd__fill_1
XFILLER_76_468 VGND VGND VPWR VPWR sky130_fd_sc_hd__decap_3
XFILLER_64_619 VGND VGND VPWR VPWR sky130_fd_sc_hd__decap_3
XFILLER_29_340 VGND VGND VPWR VPWR sky130_fd_sc_hd__fill_1
XTAP_TAPCELL_ROW_19_508 VGND VPWR sky130_fd_sc_hd__tapvpwrvgnd_1
XFILLER_29_351 VGND VGND VPWR VPWR sky130_fd_sc_hd__decap_3
XTAP_TAPCELL_ROW_19_519 VGND VPWR sky130_fd_sc_hd__tapvpwrvgnd_1
XFILLER_91_416 VGND VGND VPWR VPWR sky130_fd_sc_hd__fill_1
XFILLER_57_671 VGND VGND VPWR VPWR sky130_fd_sc_hd__fill_1
XFILLER_57_682 VGND VGND VPWR VPWR sky130_fd_sc_hd__decap_3
XFILLER_91_438 VGND VGND VPWR VPWR sky130_fd_sc_hd__decap_3
XFILLER_91_449 VGND VGND VPWR VPWR sky130_fd_sc_hd__decap_3
XTAP_TAPCELL_ROW_67_1133 VGND VPWR sky130_fd_sc_hd__tapvpwrvgnd_1
XTAP_TAPCELL_ROW_67_1144 VGND VPWR sky130_fd_sc_hd__tapvpwrvgnd_1
XFILLER_44_343 VGND VGND VPWR VPWR sky130_fd_sc_hd__decap_3
XFILLER_72_663 VGND VGND VPWR VPWR sky130_fd_sc_hd__decap_3
XFILLER_44_354 VGND VGND VPWR VPWR sky130_fd_sc_hd__decap_3
XFILLER_17_579 VGND VGND VPWR VPWR sky130_fd_sc_hd__decap_3
XFILLER_71_151 VGND VGND VPWR VPWR sky130_fd_sc_hd__decap_3
XFILLER_44_365 VGND VGND VPWR VPWR sky130_fd_sc_hd__decap_3
XFILLER_72_696 VGND VGND VPWR VPWR sky130_fd_sc_hd__decap_3
XTAP_TAPCELL_ROW_80_1311 VGND VPWR sky130_fd_sc_hd__tapvpwrvgnd_1
XFILLER_71_195 VGND VGND VPWR VPWR sky130_fd_sc_hd__decap_3
XFILLER_9_712 VGND VGND VPWR VPWR sky130_fd_sc_hd__decap_3
XFILLER_12_240 VGND VGND VPWR VPWR sky130_fd_sc_hd__decap_3
XFILLER_8_200 VGND VGND VPWR VPWR sky130_fd_sc_hd__decap_3
XFILLER_81_9 VGND VGND VPWR VPWR sky130_fd_sc_hd__decap_3
XFILLER_40_571 VGND VGND VPWR VPWR sky130_fd_sc_hd__fill_2
XFILLER_12_262 VGND VGND VPWR VPWR sky130_fd_sc_hd__decap_3
XTAP_TAPCELL_ROW_119_1808 VGND VPWR sky130_fd_sc_hd__tapvpwrvgnd_1
XTAP_TAPCELL_ROW_119_1819 VGND VPWR sky130_fd_sc_hd__tapvpwrvgnd_1
XFILLER_8_222 VGND VGND VPWR VPWR sky130_fd_sc_hd__decap_3
XFILLER_8_277 VGND VGND VPWR VPWR sky130_fd_sc_hd__decap_3
XFILLER_5_11 VGND VGND VPWR VPWR sky130_fd_sc_hd__fill_1
Xoutput508 _5649_/X VGND VGND VPWR VPWR instruction_out[26] sky130_fd_sc_hd__clkdlybuf4s25_1
Xoutput519 _5646_/Y VGND VGND VPWR VPWR instruction_out[9] sky130_fd_sc_hd__clkdlybuf4s25_1
XFILLER_99_505 VGND VGND VPWR VPWR sky130_fd_sc_hd__decap_3
XTAP_TAPCELL_ROW_78_1284 VGND VPWR sky130_fd_sc_hd__tapvpwrvgnd_1
XFILLER_5_55 VGND VGND VPWR VPWR sky130_fd_sc_hd__fill_1
XFILLER_113_337 VGND VGND VPWR VPWR sky130_fd_sc_hd__decap_3
XTAP_TAPCELL_ROW_91_1451 VGND VPWR sky130_fd_sc_hd__tapvpwrvgnd_1
XFILLER_113_359 VGND VGND VPWR VPWR sky130_fd_sc_hd__decap_3
X_4190_ _7263_/Q _4422_/A2 _4348_/B1 _7135_/Q _4189_/X VGND VGND VPWR VPWR _4637_/B
+ sky130_fd_sc_hd__a221o_2
XFILLER_69_91 VGND VGND VPWR VPWR sky130_fd_sc_hd__decap_3
XFILLER_95_700 VGND VGND VPWR VPWR sky130_fd_sc_hd__decap_3
XFILLER_79_262 VGND VGND VPWR VPWR sky130_fd_sc_hd__decap_3
XFILLER_94_221 VGND VGND VPWR VPWR sky130_fd_sc_hd__decap_3
XFILLER_10_3 VGND VGND VPWR VPWR sky130_fd_sc_hd__fill_1
XFILLER_94_265 VGND VGND VPWR VPWR sky130_fd_sc_hd__decap_3
XFILLER_67_479 VGND VGND VPWR VPWR sky130_fd_sc_hd__decap_3
XFILLER_48_660 VGND VGND VPWR VPWR sky130_fd_sc_hd__decap_3
XFILLER_82_416 VGND VGND VPWR VPWR sky130_fd_sc_hd__fill_1
X_6900_ _6942_/CLK _6900_/D VGND VGND VPWR VPWR _6900_/Q sky130_fd_sc_hd__dfxtp_2
XFILLER_48_693 VGND VGND VPWR VPWR sky130_fd_sc_hd__decap_3
XFILLER_63_641 VGND VGND VPWR VPWR sky130_fd_sc_hd__decap_3
X_6831_ clkload5/A _6831_/D VGND VGND VPWR VPWR _6831_/Q sky130_fd_sc_hd__dfxtp_2
XTAP_TAPCELL_ROW_46_861 VGND VPWR sky130_fd_sc_hd__tapvpwrvgnd_1
XFILLER_63_685 VGND VGND VPWR VPWR sky130_fd_sc_hd__decap_3
XFILLER_35_387 VGND VGND VPWR VPWR sky130_fd_sc_hd__decap_3
XFILLER_50_324 VGND VGND VPWR VPWR sky130_fd_sc_hd__decap_3
X_6762_ clkload5/A _6762_/D VGND VGND VPWR VPWR _6762_/Q sky130_fd_sc_hd__dfxtp_2
XFILLER_62_195 VGND VGND VPWR VPWR sky130_fd_sc_hd__fill_1
XFILLER_50_357 VGND VGND VPWR VPWR sky130_fd_sc_hd__decap_3
X_6693_ _7378_/CLK _6693_/D VGND VGND VPWR VPWR _6693_/Q sky130_fd_sc_hd__dfxtp_2
XFILLER_31_582 VGND VGND VPWR VPWR sky130_fd_sc_hd__decap_3
X_5644_ _6981_/Q _5130_/C _3340_/B _3327_/B VGND VGND VPWR VPWR _5644_/X sky130_fd_sc_hd__o211a_2
X_5575_ hold938/X _5587_/B _5010_/D VGND VGND VPWR VPWR _7042_/D sky130_fd_sc_hd__a21o_2
XFILLER_117_632 VGND VGND VPWR VPWR sky130_fd_sc_hd__decap_3
X_7314_ _7355_/CLK _7314_/D _6594_/Y VGND VGND VPWR VPWR _7314_/Q sky130_fd_sc_hd__dfrtp_2
X_4526_ _4526_/A0 _7284_/Q _4528_/B VGND VGND VPWR VPWR _7316_/D sky130_fd_sc_hd__mux2_2
XFILLER_117_665 VGND VGND VPWR VPWR sky130_fd_sc_hd__decap_3
XFILLER_117_676 VGND VGND VPWR VPWR sky130_fd_sc_hd__decap_3
XFILLER_104_315 VGND VGND VPWR VPWR sky130_fd_sc_hd__decap_3
X_7245_ _7406_/CLK _7245_/D _6525_/Y VGND VGND VPWR VPWR _7245_/Q sky130_fd_sc_hd__dfrtp_2
X_4457_ _4720_/A _4720_/B _4456_/X VGND VGND VPWR VPWR _4457_/X sky130_fd_sc_hd__o21a_2
XFILLER_49_28 VGND VGND VPWR VPWR sky130_fd_sc_hd__decap_3
X_7176_ _7368_/CLK _7176_/D _6456_/Y VGND VGND VPWR VPWR _7176_/Q sky130_fd_sc_hd__dfrtp_2
X_4388_ _7273_/Q _4437_/A2 _4385_/X _4387_/X VGND VGND VPWR VPWR _4388_/X sky130_fd_sc_hd__a211o_2
XFILLER_98_571 VGND VGND VPWR VPWR sky130_fd_sc_hd__decap_3
XFILLER_86_722 VGND VGND VPWR VPWR sky130_fd_sc_hd__decap_3
XFILLER_58_413 VGND VGND VPWR VPWR sky130_fd_sc_hd__fill_1
XFILLER_105_12 VGND VGND VPWR VPWR sky130_fd_sc_hd__decap_3
XFILLER_85_210 VGND VGND VPWR VPWR sky130_fd_sc_hd__decap_3
XFILLER_58_424 VGND VGND VPWR VPWR sky130_fd_sc_hd__decap_3
XFILLER_100_510 VGND VGND VPWR VPWR sky130_fd_sc_hd__decap_3
X_3339_ _3319_/X _5238_/B _3329_/Y _3339_/C1 VGND VGND VPWR VPWR _3339_/Y sky130_fd_sc_hd__a211oi_4
XFILLER_112_381 VGND VGND VPWR VPWR sky130_fd_sc_hd__decap_3
XFILLER_100_521 VGND VGND VPWR VPWR sky130_fd_sc_hd__decap_3
XFILLER_46_608 VGND VGND VPWR VPWR sky130_fd_sc_hd__decap_3
XFILLER_58_468 VGND VGND VPWR VPWR sky130_fd_sc_hd__decap_3
XFILLER_85_265 VGND VGND VPWR VPWR sky130_fd_sc_hd__decap_3
XFILLER_100_565 VGND VGND VPWR VPWR sky130_fd_sc_hd__decap_3
XFILLER_39_671 VGND VGND VPWR VPWR sky130_fd_sc_hd__fill_1
XFILLER_85_287 VGND VGND VPWR VPWR sky130_fd_sc_hd__decap_3
XFILLER_39_682 VGND VGND VPWR VPWR sky130_fd_sc_hd__decap_3
XFILLER_100_598 VGND VGND VPWR VPWR sky130_fd_sc_hd__decap_3
X_5009_ _5009_/A _5009_/B VGND VGND VPWR VPWR _5010_/D sky130_fd_sc_hd__nor2_2
XFILLER_73_449 VGND VGND VPWR VPWR sky130_fd_sc_hd__decap_3
XFILLER_38_181 VGND VGND VPWR VPWR sky130_fd_sc_hd__fill_2
XFILLER_26_321 VGND VGND VPWR VPWR sky130_fd_sc_hd__decap_3
XFILLER_38_192 VGND VGND VPWR VPWR sky130_fd_sc_hd__decap_3
XFILLER_54_663 VGND VGND VPWR VPWR sky130_fd_sc_hd__decap_3
XFILLER_26_354 VGND VGND VPWR VPWR sky130_fd_sc_hd__decap_3
XFILLER_121_33 VGND VGND VPWR VPWR sky130_fd_sc_hd__decap_3
XTAP_TAPCELL_ROW_103_1609 VGND VPWR sky130_fd_sc_hd__tapvpwrvgnd_1
XFILLER_26_365 VGND VGND VPWR VPWR sky130_fd_sc_hd__decap_3
XFILLER_81_15 VGND VGND VPWR VPWR sky130_fd_sc_hd__decap_3
XFILLER_54_696 VGND VGND VPWR VPWR sky130_fd_sc_hd__decap_3
XFILLER_121_66 VGND VGND VPWR VPWR sky130_fd_sc_hd__decap_3
XFILLER_53_184 VGND VGND VPWR VPWR sky130_fd_sc_hd__decap_3
XFILLER_14_549 VGND VGND VPWR VPWR sky130_fd_sc_hd__decap_3
XFILLER_121_99 VGND VGND VPWR VPWR sky130_fd_sc_hd__decap_3
XFILLER_41_346 VGND VGND VPWR VPWR sky130_fd_sc_hd__fill_1
XTAP_TAPCELL_ROW_24_577 VGND VPWR sky130_fd_sc_hd__tapvpwrvgnd_1
XTAP_TAPCELL_ROW_62_1074 VGND VPWR sky130_fd_sc_hd__tapvpwrvgnd_1
XFILLER_10_722 VGND VGND VPWR VPWR sky130_fd_sc_hd__decap_3
XFILLER_14_75 VGND VGND VPWR VPWR sky130_fd_sc_hd__decap_3
XFILLER_6_704 VGND VGND VPWR VPWR sky130_fd_sc_hd__decap_3
XFILLER_14_97 VGND VGND VPWR VPWR sky130_fd_sc_hd__decap_3
XFILLER_108_610 VGND VGND VPWR VPWR sky130_fd_sc_hd__decap_3
XFILLER_108_643 VGND VGND VPWR VPWR sky130_fd_sc_hd__fill_1
XFILLER_108_654 VGND VGND VPWR VPWR sky130_fd_sc_hd__decap_3
XFILLER_107_131 VGND VGND VPWR VPWR sky130_fd_sc_hd__decap_3
XFILLER_108_687 VGND VGND VPWR VPWR sky130_fd_sc_hd__decap_3
XFILLER_107_164 VGND VGND VPWR VPWR sky130_fd_sc_hd__decap_3
XTAP_TAPCELL_ROW_114_1749 VGND VPWR sky130_fd_sc_hd__tapvpwrvgnd_1
XFILLER_30_85 VGND VGND VPWR VPWR sky130_fd_sc_hd__decap_3
XFILLER_107_175 VGND VGND VPWR VPWR sky130_fd_sc_hd__decap_3
XFILLER_123_635 VGND VGND VPWR VPWR sky130_fd_sc_hd__decap_3
XFILLER_123_668 VGND VGND VPWR VPWR sky130_fd_sc_hd__decap_3
XFILLER_77_700 VGND VGND VPWR VPWR sky130_fd_sc_hd__decap_3
XFILLER_89_582 VGND VGND VPWR VPWR sky130_fd_sc_hd__decap_3
XFILLER_1_486 VGND VGND VPWR VPWR sky130_fd_sc_hd__fill_1
XFILLER_39_72 VGND VGND VPWR VPWR sky130_fd_sc_hd__decap_3
XFILLER_76_243 VGND VGND VPWR VPWR sky130_fd_sc_hd__decap_3
XFILLER_76_265 VGND VGND VPWR VPWR sky130_fd_sc_hd__decap_3
XFILLER_92_725 VGND VGND VPWR VPWR sky130_fd_sc_hd__decap_3
XFILLER_64_416 VGND VGND VPWR VPWR sky130_fd_sc_hd__decap_3
XFILLER_91_213 VGND VGND VPWR VPWR sky130_fd_sc_hd__decap_3
XPHY_EDGE_ROW_101_Right_101 VGND VGND VPWR VPWR sky130_fd_sc_hd__decap_3
XFILLER_17_310 VGND VGND VPWR VPWR sky130_fd_sc_hd__decap_3
XFILLER_91_246 VGND VGND VPWR VPWR sky130_fd_sc_hd__decap_3
XFILLER_45_641 VGND VGND VPWR VPWR sky130_fd_sc_hd__decap_3
XFILLER_55_60 VGND VGND VPWR VPWR sky130_fd_sc_hd__decap_3
XFILLER_45_685 VGND VGND VPWR VPWR sky130_fd_sc_hd__decap_3
XFILLER_17_376 VGND VGND VPWR VPWR sky130_fd_sc_hd__decap_3
XFILLER_60_622 VGND VGND VPWR VPWR sky130_fd_sc_hd__decap_3
XTAP_TAPCELL_ROW_43_820 VGND VPWR sky130_fd_sc_hd__tapvpwrvgnd_1
XFILLER_44_173 VGND VGND VPWR VPWR sky130_fd_sc_hd__fill_2
XFILLER_32_324 VGND VGND VPWR VPWR sky130_fd_sc_hd__decap_3
XTAP_TAPCELL_ROW_43_831 VGND VPWR sky130_fd_sc_hd__tapvpwrvgnd_1
XFILLER_60_666 VGND VGND VPWR VPWR sky130_fd_sc_hd__decap_3
XFILLER_32_357 VGND VGND VPWR VPWR sky130_fd_sc_hd__decap_3
XFILLER_32_368 VGND VGND VPWR VPWR sky130_fd_sc_hd__decap_3
XFILLER_60_699 VGND VGND VPWR VPWR sky130_fd_sc_hd__fill_1
XFILLER_13_582 VGND VGND VPWR VPWR sky130_fd_sc_hd__decap_3
XFILLER_9_553 VGND VGND VPWR VPWR sky130_fd_sc_hd__decap_3
XFILLER_9_564 VGND VGND VPWR VPWR sky130_fd_sc_hd__decap_3
XFILLER_9_597 VGND VGND VPWR VPWR sky130_fd_sc_hd__decap_3
X_5360_ _5360_/A0 _4470_/X _7412_/A VGND VGND VPWR VPWR _7151_/D sky130_fd_sc_hd__mux2_2
XFILLER_114_613 VGND VGND VPWR VPWR sky130_fd_sc_hd__decap_3
X_4311_ _4311_/A _4311_/B _4311_/C VGND VGND VPWR VPWR _4311_/X sky130_fd_sc_hd__or3_2
XFILLER_114_657 VGND VGND VPWR VPWR sky130_fd_sc_hd__decap_3
X_7030_ _7313_/CLK _7030_/D _6310_/Y VGND VGND VPWR VPWR _7030_/Q sky130_fd_sc_hd__dfrtp_2
XFILLER_87_508 VGND VGND VPWR VPWR sky130_fd_sc_hd__fill_1
XFILLER_113_156 VGND VGND VPWR VPWR sky130_fd_sc_hd__decap_3
XFILLER_68_722 VGND VGND VPWR VPWR sky130_fd_sc_hd__decap_3
X_4173_ _7072_/Q VGND VGND VPWR VPWR _4173_/Y sky130_fd_sc_hd__inv_2
XFILLER_95_530 VGND VGND VPWR VPWR sky130_fd_sc_hd__decap_3
XFILLER_122_690 VGND VGND VPWR VPWR sky130_fd_sc_hd__decap_3
XFILLER_83_703 VGND VGND VPWR VPWR sky130_fd_sc_hd__decap_3
XFILLER_28_619 VGND VGND VPWR VPWR sky130_fd_sc_hd__decap_3
XFILLER_55_405 VGND VGND VPWR VPWR sky130_fd_sc_hd__decap_3
XFILLER_95_585 VGND VGND VPWR VPWR sky130_fd_sc_hd__decap_3
XFILLER_67_287 VGND VGND VPWR VPWR sky130_fd_sc_hd__decap_3
XFILLER_48_490 VGND VGND VPWR VPWR sky130_fd_sc_hd__decap_3
XFILLER_82_268 VGND VGND VPWR VPWR sky130_fd_sc_hd__decap_3
XFILLER_36_663 VGND VGND VPWR VPWR sky130_fd_sc_hd__decap_3
XFILLER_70_419 VGND VGND VPWR VPWR sky130_fd_sc_hd__fill_1
XFILLER_23_302 VGND VGND VPWR VPWR sky130_fd_sc_hd__decap_3
XFILLER_36_696 VGND VGND VPWR VPWR sky130_fd_sc_hd__decap_3
XFILLER_35_162 VGND VGND VPWR VPWR sky130_fd_sc_hd__decap_3
XFILLER_63_482 VGND VGND VPWR VPWR sky130_fd_sc_hd__decap_3
X_6814_ clkload9/A _6814_/D VGND VGND VPWR VPWR _6814_/Q sky130_fd_sc_hd__dfxtp_2
Xplace460 _6979_/Q VGND VGND VPWR VPWR _5129_/B sky130_fd_sc_hd__buf_2
XFILLER_51_644 VGND VGND VPWR VPWR sky130_fd_sc_hd__decap_3
XFILLER_50_121 VGND VGND VPWR VPWR sky130_fd_sc_hd__fill_1
XFILLER_23_335 VGND VGND VPWR VPWR sky130_fd_sc_hd__fill_1
XFILLER_23_346 VGND VGND VPWR VPWR sky130_fd_sc_hd__decap_3
XFILLER_50_154 VGND VGND VPWR VPWR sky130_fd_sc_hd__decap_3
X_6745_ _6967_/CLK _6745_/D VGND VGND VPWR VPWR _6745_/Q sky130_fd_sc_hd__dfxtp_2
XFILLER_51_688 VGND VGND VPWR VPWR sky130_fd_sc_hd__decap_3
XFILLER_50_187 VGND VGND VPWR VPWR sky130_fd_sc_hd__decap_3
XTAP_TAPCELL_ROW_21_536 VGND VPWR sky130_fd_sc_hd__tapvpwrvgnd_1
X_6676_ _6686_/A VGND VGND VPWR VPWR _6676_/Y sky130_fd_sc_hd__inv_2
X_3888_ _6844_/Q _3888_/A2 _3891_/B1 _6839_/Q VGND VGND VPWR VPWR _3888_/X sky130_fd_sc_hd__a22o_2
XFILLER_3_718 VGND VGND VPWR VPWR sky130_fd_sc_hd__decap_3
XFILLER_3_729 VGND VGND VPWR VPWR sky130_fd_sc_hd__decap_3
XFILLER_2_206 VGND VGND VPWR VPWR sky130_fd_sc_hd__decap_3
XFILLER_117_473 VGND VGND VPWR VPWR sky130_fd_sc_hd__decap_3
X_4509_ hold982/X _3398_/Y _4244_/X VGND VGND VPWR VPWR _7325_/D sky130_fd_sc_hd__a21o_2
XFILLER_105_635 VGND VGND VPWR VPWR sky130_fd_sc_hd__decap_3
XFILLER_116_11 VGND VGND VPWR VPWR sky130_fd_sc_hd__decap_3
XFILLER_104_134 VGND VGND VPWR VPWR sky130_fd_sc_hd__decap_3
XFILLER_105_668 VGND VGND VPWR VPWR sky130_fd_sc_hd__decap_3
X_7228_ _7392_/CLK _7228_/D _6508_/Y VGND VGND VPWR VPWR _7228_/Q sky130_fd_sc_hd__dfrtp_2
XFILLER_78_519 VGND VGND VPWR VPWR sky130_fd_sc_hd__decap_3
XFILLER_105_679 VGND VGND VPWR VPWR sky130_fd_sc_hd__decap_3
XFILLER_104_156 VGND VGND VPWR VPWR sky130_fd_sc_hd__fill_1
XFILLER_59_700 VGND VGND VPWR VPWR sky130_fd_sc_hd__decap_3
XFILLER_120_616 VGND VGND VPWR VPWR sky130_fd_sc_hd__decap_3
XFILLER_116_44 VGND VGND VPWR VPWR sky130_fd_sc_hd__decap_3
XFILLER_104_178 VGND VGND VPWR VPWR sky130_fd_sc_hd__decap_3
XFILLER_76_26 VGND VGND VPWR VPWR sky130_fd_sc_hd__fill_2
XFILLER_58_210 VGND VGND VPWR VPWR sky130_fd_sc_hd__decap_3
XFILLER_116_77 VGND VGND VPWR VPWR sky130_fd_sc_hd__decap_3
X_7159_ _7325_/CLK _7159_/D _6439_/Y VGND VGND VPWR VPWR _7159_/Q sky130_fd_sc_hd__dfrtp_2
XFILLER_116_88 VGND VGND VPWR VPWR sky130_fd_sc_hd__decap_3
XFILLER_100_340 VGND VGND VPWR VPWR sky130_fd_sc_hd__decap_3
XFILLER_86_574 VGND VGND VPWR VPWR sky130_fd_sc_hd__decap_3
XFILLER_74_725 VGND VGND VPWR VPWR sky130_fd_sc_hd__decap_3
XFILLER_58_276 VGND VGND VPWR VPWR sky130_fd_sc_hd__decap_3
XFILLER_100_362 VGND VGND VPWR VPWR sky130_fd_sc_hd__fill_2
XFILLER_46_427 VGND VGND VPWR VPWR sky130_fd_sc_hd__fill_1
XFILLER_18_118 VGND VGND VPWR VPWR sky130_fd_sc_hd__decap_3
XFILLER_58_298 VGND VGND VPWR VPWR sky130_fd_sc_hd__fill_2
XTAP_TAPCELL_ROW_29_647 VGND VPWR sky130_fd_sc_hd__tapvpwrvgnd_1
Xclkbuf_leaf_38_clk clkbuf_leaf_2_clk/A VGND VGND VPWR VPWR _7387_/CLK sky130_fd_sc_hd__clkbuf_16
XFILLER_73_246 VGND VGND VPWR VPWR sky130_fd_sc_hd__decap_3
XFILLER_27_641 VGND VGND VPWR VPWR sky130_fd_sc_hd__decap_3
XTAP_TAPCELL_ROW_64_1103 VGND VPWR sky130_fd_sc_hd__tapvpwrvgnd_1
XTAP_TAPCELL_ROW_1_283 VGND VPWR sky130_fd_sc_hd__tapvpwrvgnd_1
XFILLER_27_685 VGND VGND VPWR VPWR sky130_fd_sc_hd__decap_3
XFILLER_42_622 VGND VGND VPWR VPWR sky130_fd_sc_hd__decap_3
XFILLER_54_493 VGND VGND VPWR VPWR sky130_fd_sc_hd__decap_3
XFILLER_26_195 VGND VGND VPWR VPWR sky130_fd_sc_hd__fill_1
XFILLER_14_346 VGND VGND VPWR VPWR sky130_fd_sc_hd__decap_3
XFILLER_42_666 VGND VGND VPWR VPWR sky130_fd_sc_hd__decap_3
XFILLER_25_74 VGND VGND VPWR VPWR sky130_fd_sc_hd__fill_1
XFILLER_41_154 VGND VGND VPWR VPWR sky130_fd_sc_hd__fill_2
XFILLER_14_368 VGND VGND VPWR VPWR sky130_fd_sc_hd__decap_3
XFILLER_42_699 VGND VGND VPWR VPWR sky130_fd_sc_hd__fill_1
XFILLER_10_563 VGND VGND VPWR VPWR sky130_fd_sc_hd__decap_3
XFILLER_6_545 VGND VGND VPWR VPWR sky130_fd_sc_hd__decap_3
XFILLER_6_578 VGND VGND VPWR VPWR sky130_fd_sc_hd__decap_3
XFILLER_6_589 VGND VGND VPWR VPWR sky130_fd_sc_hd__decap_3
XFILLER_108_473 VGND VGND VPWR VPWR sky130_fd_sc_hd__decap_3
XTAP_TAPCELL_ROW_75_1243 VGND VPWR sky130_fd_sc_hd__tapvpwrvgnd_1
XFILLER_123_421 VGND VGND VPWR VPWR sky130_fd_sc_hd__decap_3
XFILLER_123_443 VGND VGND VPWR VPWR sky130_fd_sc_hd__decap_3
XFILLER_69_519 VGND VGND VPWR VPWR sky130_fd_sc_hd__decap_3
XTAP_TAPCELL_ROW_9_383 VGND VPWR sky130_fd_sc_hd__tapvpwrvgnd_1
XFILLER_111_638 VGND VGND VPWR VPWR sky130_fd_sc_hd__decap_3
XFILLER_96_338 VGND VGND VPWR VPWR sky130_fd_sc_hd__decap_3
XFILLER_49_210 VGND VGND VPWR VPWR sky130_fd_sc_hd__fill_1
XFILLER_2_12 VGND VGND VPWR VPWR sky130_fd_sc_hd__decap_3
XFILLER_104_690 VGND VGND VPWR VPWR sky130_fd_sc_hd__decap_3
XFILLER_77_530 VGND VGND VPWR VPWR sky130_fd_sc_hd__fill_2
XFILLER_49_243 VGND VGND VPWR VPWR sky130_fd_sc_hd__decap_3
XFILLER_110_159 VGND VGND VPWR VPWR sky130_fd_sc_hd__decap_3
XFILLER_65_703 VGND VGND VPWR VPWR sky130_fd_sc_hd__decap_3
XFILLER_49_287 VGND VGND VPWR VPWR sky130_fd_sc_hd__decap_3
XFILLER_64_224 VGND VGND VPWR VPWR sky130_fd_sc_hd__decap_3
XFILLER_37_438 VGND VGND VPWR VPWR sky130_fd_sc_hd__decap_3
XFILLER_66_81 VGND VGND VPWR VPWR sky130_fd_sc_hd__decap_3
XFILLER_37_449 VGND VGND VPWR VPWR sky130_fd_sc_hd__decap_3
Xclkbuf_leaf_29_clk clkload1/A VGND VGND VPWR VPWR _7325_/CLK sky130_fd_sc_hd__clkbuf_16
XFILLER_92_544 VGND VGND VPWR VPWR sky130_fd_sc_hd__decap_3
XFILLER_92_577 VGND VGND VPWR VPWR sky130_fd_sc_hd__decap_3
XFILLER_64_268 VGND VGND VPWR VPWR sky130_fd_sc_hd__decap_3
XFILLER_18_663 VGND VGND VPWR VPWR sky130_fd_sc_hd__decap_3
XFILLER_80_728 VGND VGND VPWR VPWR sky130_fd_sc_hd__decap_3
XFILLER_33_611 VGND VGND VPWR VPWR sky130_fd_sc_hd__decap_3
XFILLER_18_696 VGND VGND VPWR VPWR sky130_fd_sc_hd__decap_3
XTAP_TAPCELL_ROW_86_1383 VGND VPWR sky130_fd_sc_hd__tapvpwrvgnd_1
X_4860_ _4687_/B _4859_/Y _5015_/A VGND VGND VPWR VPWR _4860_/Y sky130_fd_sc_hd__o21ai_2
XFILLER_33_644 VGND VGND VPWR VPWR sky130_fd_sc_hd__decap_3
XFILLER_17_195 VGND VGND VPWR VPWR sky130_fd_sc_hd__fill_1
XFILLER_82_80 VGND VGND VPWR VPWR sky130_fd_sc_hd__decap_3
X_3811_ _3923_/A1 _3808_/X _3810_/X _3741_/X VGND VGND VPWR VPWR _3811_/X sky130_fd_sc_hd__a22o_2
XFILLER_82_91 VGND VGND VPWR VPWR sky130_fd_sc_hd__decap_3
XFILLER_60_463 VGND VGND VPWR VPWR sky130_fd_sc_hd__decap_3
XFILLER_33_688 VGND VGND VPWR VPWR sky130_fd_sc_hd__decap_3
X_4791_ _4791_/A1 _5664_/A _3697_/Y _4791_/C1 VGND VGND VPWR VPWR _4791_/Y sky130_fd_sc_hd__a211oi_2
XANTENNA_17 _5667_/A VGND VGND VPWR VPWR sky130_fd_sc_hd__diode_2
XFILLER_20_327 VGND VGND VPWR VPWR sky130_fd_sc_hd__decap_3
X_6530_ _6602_/A VGND VGND VPWR VPWR _6530_/Y sky130_fd_sc_hd__inv_2
X_3742_ _6833_/Q _3656_/Y _3892_/B1 _6843_/Q VGND VGND VPWR VPWR _3742_/X sky130_fd_sc_hd__a22o_2
XFILLER_119_727 VGND VGND VPWR VPWR sky130_fd_sc_hd__fill_1
X_6461_ _6619_/A VGND VGND VPWR VPWR _6461_/Y sky130_fd_sc_hd__inv_2
X_3673_ _6856_/Q _6864_/Q _6904_/Q _6912_/Q _3991_/B _3665_/B VGND VGND VPWR VPWR
+ _3673_/X sky130_fd_sc_hd__mux4_2
XFILLER_118_248 VGND VGND VPWR VPWR sky130_fd_sc_hd__decap_3
X_6392_ _6618_/A VGND VGND VPWR VPWR _6392_/Y sky130_fd_sc_hd__inv_2
XFILLER_114_421 VGND VGND VPWR VPWR sky130_fd_sc_hd__fill_1
X_5274_ hold990/X _5079_/X _5292_/S VGND VGND VPWR VPWR _7193_/D sky130_fd_sc_hd__mux2_2
XFILLER_87_305 VGND VGND VPWR VPWR sky130_fd_sc_hd__fill_2
XFILLER_102_616 VGND VGND VPWR VPWR sky130_fd_sc_hd__decap_3
XFILLER_99_187 VGND VGND VPWR VPWR sky130_fd_sc_hd__decap_3
X_7013_ _7325_/CLK _7013_/D _6293_/Y VGND VGND VPWR VPWR _7013_/Q sky130_fd_sc_hd__dfrtp_2
X_4225_ _4371_/A _4371_/B _4224_/C VGND VGND VPWR VPWR _4627_/A sky130_fd_sc_hd__a21oi_2
XFILLER_87_349 VGND VGND VPWR VPWR sky130_fd_sc_hd__fill_2
X_4156_ _4157_/A _4205_/C VGND VGND VPWR VPWR _4158_/A sky130_fd_sc_hd__or2_2
XFILLER_110_660 VGND VGND VPWR VPWR sky130_fd_sc_hd__decap_3
XFILLER_95_371 VGND VGND VPWR VPWR sky130_fd_sc_hd__fill_1
XFILLER_83_511 VGND VGND VPWR VPWR sky130_fd_sc_hd__fill_2
XFILLER_56_725 VGND VGND VPWR VPWR sky130_fd_sc_hd__decap_3
XFILLER_46_29 VGND VGND VPWR VPWR sky130_fd_sc_hd__decap_3
XFILLER_110_693 VGND VGND VPWR VPWR sky130_fd_sc_hd__decap_3
XFILLER_95_393 VGND VGND VPWR VPWR sky130_fd_sc_hd__decap_3
X_4087_ _7078_/Q _4102_/B _4432_/B1 _4086_/X VGND VGND VPWR VPWR _4095_/A sky130_fd_sc_hd__o211ai_2
XFILLER_71_706 VGND VGND VPWR VPWR sky130_fd_sc_hd__decap_3
XTAP_TAPCELL_ROW_26_606 VGND VPWR sky130_fd_sc_hd__tapvpwrvgnd_1
XFILLER_83_588 VGND VGND VPWR VPWR sky130_fd_sc_hd__decap_3
XFILLER_70_205 VGND VGND VPWR VPWR sky130_fd_sc_hd__decap_3
XFILLER_55_279 VGND VGND VPWR VPWR sky130_fd_sc_hd__fill_1
XFILLER_102_24 VGND VGND VPWR VPWR sky130_fd_sc_hd__decap_3
XFILLER_24_622 VGND VGND VPWR VPWR sky130_fd_sc_hd__decap_3
XFILLER_24_666 VGND VGND VPWR VPWR sky130_fd_sc_hd__decap_3
XFILLER_51_452 VGND VGND VPWR VPWR sky130_fd_sc_hd__decap_3
XFILLER_23_143 VGND VGND VPWR VPWR sky130_fd_sc_hd__decap_3
Xplace290 _3656_/Y VGND VGND VPWR VPWR _3878_/A2 sky130_fd_sc_hd__buf_2
XFILLER_24_699 VGND VGND VPWR VPWR sky130_fd_sc_hd__fill_1
X_4989_ _5032_/A _5032_/B VGND VGND VPWR VPWR _4989_/X sky130_fd_sc_hd__or2b_2
XFILLER_23_198 VGND VGND VPWR VPWR sky130_fd_sc_hd__decap_3
X_6728_ _6978_/CLK _6728_/D VGND VGND VPWR VPWR _6728_/Q sky130_fd_sc_hd__dfxtp_2
XFILLER_11_349 VGND VGND VPWR VPWR sky130_fd_sc_hd__fill_2
X_6659_ _6660_/A VGND VGND VPWR VPWR _6659_/Y sky130_fd_sc_hd__inv_2
XFILLER_3_526 VGND VGND VPWR VPWR sky130_fd_sc_hd__decap_3
XFILLER_11_76 VGND VGND VPWR VPWR sky130_fd_sc_hd__decap_3
XFILLER_117_281 VGND VGND VPWR VPWR sky130_fd_sc_hd__decap_3
XTAP_TAPCELL_ROW_111_1708 VGND VPWR sky130_fd_sc_hd__tapvpwrvgnd_1
XFILLER_3_559 VGND VGND VPWR VPWR sky130_fd_sc_hd__fill_1
XFILLER_87_36 VGND VGND VPWR VPWR sky130_fd_sc_hd__fill_1
XFILLER_120_413 VGND VGND VPWR VPWR sky130_fd_sc_hd__decap_3
XTAP_TAPCELL_ROW_6_342 VGND VPWR sky130_fd_sc_hd__tapvpwrvgnd_1
XFILLER_78_349 VGND VGND VPWR VPWR sky130_fd_sc_hd__fill_1
XFILLER_120_457 VGND VGND VPWR VPWR sky130_fd_sc_hd__decap_3
XTAP_TAPCELL_ROW_70_1173 VGND VPWR sky130_fd_sc_hd__tapvpwrvgnd_1
XFILLER_47_703 VGND VGND VPWR VPWR sky130_fd_sc_hd__decap_3
XFILLER_19_405 VGND VGND VPWR VPWR sky130_fd_sc_hd__decap_3
XFILLER_101_671 VGND VGND VPWR VPWR sky130_fd_sc_hd__fill_1
XFILLER_86_371 VGND VGND VPWR VPWR sky130_fd_sc_hd__fill_1
XFILLER_101_682 VGND VGND VPWR VPWR sky130_fd_sc_hd__decap_3
XFILLER_86_382 VGND VGND VPWR VPWR sky130_fd_sc_hd__decap_3
XFILLER_46_213 VGND VGND VPWR VPWR sky130_fd_sc_hd__decap_3
XFILLER_74_544 VGND VGND VPWR VPWR sky130_fd_sc_hd__decap_3
XFILLER_46_268 VGND VGND VPWR VPWR sky130_fd_sc_hd__decap_3
XFILLER_62_728 VGND VGND VPWR VPWR sky130_fd_sc_hd__decap_3
XFILLER_34_419 VGND VGND VPWR VPWR sky130_fd_sc_hd__fill_1
XFILLER_15_600 VGND VGND VPWR VPWR sky130_fd_sc_hd__decap_3
XFILLER_36_62 VGND VGND VPWR VPWR sky130_fd_sc_hd__fill_1
XFILLER_36_73 VGND VGND VPWR VPWR sky130_fd_sc_hd__decap_3
XFILLER_61_249 VGND VGND VPWR VPWR sky130_fd_sc_hd__decap_3
XFILLER_15_644 VGND VGND VPWR VPWR sky130_fd_sc_hd__decap_3
XTAP_TAPCELL_ROW_122_1848 VGND VPWR sky130_fd_sc_hd__tapvpwrvgnd_1
XFILLER_54_290 VGND VGND VPWR VPWR sky130_fd_sc_hd__decap_3
XFILLER_42_430 VGND VGND VPWR VPWR sky130_fd_sc_hd__fill_2
XTAP_TAPCELL_ROW_122_1859 VGND VPWR sky130_fd_sc_hd__tapvpwrvgnd_1
XFILLER_15_688 VGND VGND VPWR VPWR sky130_fd_sc_hd__decap_3
XFILLER_30_625 VGND VGND VPWR VPWR sky130_fd_sc_hd__decap_3
XFILLER_52_50 VGND VGND VPWR VPWR sky130_fd_sc_hd__fill_1
XFILLER_30_669 VGND VGND VPWR VPWR sky130_fd_sc_hd__decap_3
XFILLER_116_719 VGND VGND VPWR VPWR sky130_fd_sc_hd__decap_3
XFILLER_97_603 VGND VGND VPWR VPWR sky130_fd_sc_hd__decap_3
XFILLER_69_327 VGND VGND VPWR VPWR sky130_fd_sc_hd__decap_3
XFILLER_97_647 VGND VGND VPWR VPWR sky130_fd_sc_hd__decap_3
XFILLER_2_581 VGND VGND VPWR VPWR sky130_fd_sc_hd__decap_3
XFILLER_123_284 VGND VGND VPWR VPWR sky130_fd_sc_hd__fill_1
XFILLER_111_424 VGND VGND VPWR VPWR sky130_fd_sc_hd__decap_3
XFILLER_2_592 VGND VGND VPWR VPWR sky130_fd_sc_hd__decap_3
XFILLER_111_479 VGND VGND VPWR VPWR sky130_fd_sc_hd__decap_3
XFILLER_38_725 VGND VGND VPWR VPWR sky130_fd_sc_hd__decap_3
XTAP_TAPCELL_ROW_88_1412 VGND VPWR sky130_fd_sc_hd__tapvpwrvgnd_1
XFILLER_37_246 VGND VGND VPWR VPWR sky130_fd_sc_hd__decap_3
XFILLER_92_352 VGND VGND VPWR VPWR sky130_fd_sc_hd__decap_3
XFILLER_53_706 VGND VGND VPWR VPWR sky130_fd_sc_hd__decap_3
XFILLER_37_268 VGND VGND VPWR VPWR sky130_fd_sc_hd__decap_3
XFILLER_80_547 VGND VGND VPWR VPWR sky130_fd_sc_hd__fill_1
X_4912_ _4912_/A _4912_/B VGND VGND VPWR VPWR _6997_/D sky130_fd_sc_hd__nor2_2
XFILLER_45_290 VGND VGND VPWR VPWR sky130_fd_sc_hd__decap_3
XFILLER_33_441 VGND VGND VPWR VPWR sky130_fd_sc_hd__decap_3
XTAP_TAPCELL_ROW_51_929 VGND VPWR sky130_fd_sc_hd__tapvpwrvgnd_1
X_4843_ _4111_/B _4842_/X _4633_/A VGND VGND VPWR VPWR _4843_/Y sky130_fd_sc_hd__a21oi_2
XFILLER_21_647 VGND VGND VPWR VPWR sky130_fd_sc_hd__decap_3
XFILLER_20_135 VGND VGND VPWR VPWR sky130_fd_sc_hd__decap_3
X_4774_ _7004_/Q _4801_/A VGND VGND VPWR VPWR _4775_/B sky130_fd_sc_hd__nor2_2
XFILLER_119_502 VGND VGND VPWR VPWR sky130_fd_sc_hd__fill_2
XTAP_TAPCELL_ROW_31_664 VGND VPWR sky130_fd_sc_hd__tapvpwrvgnd_1
X_6513_ _6643_/A VGND VGND VPWR VPWR _6513_/Y sky130_fd_sc_hd__inv_2
XTAP_TAPCELL_ROW_31_675 VGND VPWR sky130_fd_sc_hd__tapvpwrvgnd_1
XTAP_TAPCELL_ROW_99_1552 VGND VPWR sky130_fd_sc_hd__tapvpwrvgnd_1
X_3725_ _3735_/A _3741_/B _3733_/C VGND VGND VPWR VPWR _3725_/X sky130_fd_sc_hd__and3_2
XFILLER_119_535 VGND VGND VPWR VPWR sky130_fd_sc_hd__decap_3
X_6444_ _6544_/A VGND VGND VPWR VPWR _6444_/Y sky130_fd_sc_hd__inv_2
Xclkbuf_leaf_9_clk clkbuf_leaf_9_clk/A VGND VGND VPWR VPWR _7401_/CLK sky130_fd_sc_hd__clkbuf_16
XFILLER_119_579 VGND VGND VPWR VPWR sky130_fd_sc_hd__decap_3
X_3656_ _3991_/B _3665_/B VGND VGND VPWR VPWR _3656_/Y sky130_fd_sc_hd__nor2_2
X_6375_ _6568_/A VGND VGND VPWR VPWR _6375_/Y sky130_fd_sc_hd__inv_2
X_3587_ _3599_/A _3600_/A VGND VGND VPWR VPWR _4292_/B sky130_fd_sc_hd__or2_4
XFILLER_114_240 VGND VGND VPWR VPWR sky130_fd_sc_hd__decap_3
XFILLER_88_625 VGND VGND VPWR VPWR sky130_fd_sc_hd__decap_3
XFILLER_114_262 VGND VGND VPWR VPWR sky130_fd_sc_hd__fill_1
XFILLER_87_113 VGND VGND VPWR VPWR sky130_fd_sc_hd__decap_3
XFILLER_102_413 VGND VGND VPWR VPWR sky130_fd_sc_hd__decap_3
XFILLER_114_284 VGND VGND VPWR VPWR sky130_fd_sc_hd__decap_3
XFILLER_88_669 VGND VGND VPWR VPWR sky130_fd_sc_hd__decap_3
XFILLER_87_146 VGND VGND VPWR VPWR sky130_fd_sc_hd__decap_3
XFILLER_29_703 VGND VGND VPWR VPWR sky130_fd_sc_hd__decap_3
XTAP_TAPCELL_ROW_3_301 VGND VPWR sky130_fd_sc_hd__tapvpwrvgnd_1
X_4208_ _4886_/A _4208_/B VGND VGND VPWR VPWR _4903_/A sky130_fd_sc_hd__nor2_2
XTAP_TAPCELL_ROW_3_312 VGND VPWR sky130_fd_sc_hd__tapvpwrvgnd_1
X_5188_ _5188_/A _5207_/B VGND VGND VPWR VPWR _7234_/D sky130_fd_sc_hd__and2_2
XFILLER_56_522 VGND VGND VPWR VPWR sky130_fd_sc_hd__fill_2
XFILLER_113_12 VGND VGND VPWR VPWR sky130_fd_sc_hd__decap_3
XFILLER_28_224 VGND VGND VPWR VPWR sky130_fd_sc_hd__decap_3
X_4139_ _4207_/A _4642_/B VGND VGND VPWR VPWR _4886_/A sky130_fd_sc_hd__nor2_2
XFILLER_113_45 VGND VGND VPWR VPWR sky130_fd_sc_hd__decap_3
XTAP_TAPCELL_ROW_39_775 VGND VPWR sky130_fd_sc_hd__tapvpwrvgnd_1
XFILLER_71_503 VGND VGND VPWR VPWR sky130_fd_sc_hd__fill_1
XFILLER_44_728 VGND VGND VPWR VPWR sky130_fd_sc_hd__decap_3
XFILLER_16_419 VGND VGND VPWR VPWR sky130_fd_sc_hd__fill_1
XFILLER_73_27 VGND VGND VPWR VPWR sky130_fd_sc_hd__decap_3
XFILLER_113_78 VGND VGND VPWR VPWR sky130_fd_sc_hd__decap_3
XFILLER_71_525 VGND VGND VPWR VPWR sky130_fd_sc_hd__decap_3
XFILLER_43_216 VGND VGND VPWR VPWR sky130_fd_sc_hd__decap_3
XTAP_TAPCELL_ROW_108_1670 VGND VPWR sky130_fd_sc_hd__tapvpwrvgnd_1
XFILLER_83_396 VGND VGND VPWR VPWR sky130_fd_sc_hd__decap_3
XFILLER_43_249 VGND VGND VPWR VPWR sky130_fd_sc_hd__decap_3
XFILLER_24_430 VGND VGND VPWR VPWR sky130_fd_sc_hd__decap_3
XFILLER_24_463 VGND VGND VPWR VPWR sky130_fd_sc_hd__fill_1
XFILLER_24_474 VGND VGND VPWR VPWR sky130_fd_sc_hd__fill_2
XFILLER_12_625 VGND VGND VPWR VPWR sky130_fd_sc_hd__decap_3
XFILLER_11_113 VGND VGND VPWR VPWR sky130_fd_sc_hd__decap_3
XFILLER_8_607 VGND VGND VPWR VPWR sky130_fd_sc_hd__decap_3
XFILLER_12_669 VGND VGND VPWR VPWR sky130_fd_sc_hd__decap_3
XTAP_TAPCELL_ROW_59_1035 VGND VPWR sky130_fd_sc_hd__tapvpwrvgnd_1
XFILLER_98_24 VGND VGND VPWR VPWR sky130_fd_sc_hd__decap_3
XFILLER_98_35 VGND VGND VPWR VPWR sky130_fd_sc_hd__fill_1
XTAP_TAPCELL_ROW_72_1202 VGND VPWR sky130_fd_sc_hd__tapvpwrvgnd_1
XFILLER_98_79 VGND VGND VPWR VPWR sky130_fd_sc_hd__decap_3
XFILLER_79_603 VGND VGND VPWR VPWR sky130_fd_sc_hd__decap_3
XFILLER_3_367 VGND VGND VPWR VPWR sky130_fd_sc_hd__decap_3
XFILLER_121_700 VGND VGND VPWR VPWR sky130_fd_sc_hd__decap_3
XFILLER_79_647 VGND VGND VPWR VPWR sky130_fd_sc_hd__decap_3
XFILLER_78_124 VGND VGND VPWR VPWR sky130_fd_sc_hd__decap_3
XFILLER_120_243 VGND VGND VPWR VPWR sky130_fd_sc_hd__decap_3
XFILLER_94_628 VGND VGND VPWR VPWR sky130_fd_sc_hd__decap_3
XFILLER_93_116 VGND VGND VPWR VPWR sky130_fd_sc_hd__decap_3
XFILLER_59_371 VGND VGND VPWR VPWR sky130_fd_sc_hd__decap_3
XFILLER_87_691 VGND VGND VPWR VPWR sky130_fd_sc_hd__decap_3
XFILLER_59_393 VGND VGND VPWR VPWR sky130_fd_sc_hd__decap_3
XFILLER_86_190 VGND VGND VPWR VPWR sky130_fd_sc_hd__decap_3
XFILLER_47_83 VGND VGND VPWR VPWR sky130_fd_sc_hd__fill_2
XFILLER_35_706 VGND VGND VPWR VPWR sky130_fd_sc_hd__decap_3
XFILLER_74_363 VGND VGND VPWR VPWR sky130_fd_sc_hd__fill_1
XFILLER_74_374 VGND VGND VPWR VPWR sky130_fd_sc_hd__decap_3
XFILLER_62_514 VGND VGND VPWR VPWR sky130_fd_sc_hd__decap_3
XFILLER_34_216 VGND VGND VPWR VPWR sky130_fd_sc_hd__decap_3
XTAP_TAPCELL_ROW_83_1342 VGND VPWR sky130_fd_sc_hd__tapvpwrvgnd_1
Xclkbuf_3_4__f_clk clkbuf_0_clk/X VGND VGND VPWR VPWR clkbuf_leaf_9_clk/A sky130_fd_sc_hd__clkbuf_16
XFILLER_30_400 VGND VGND VPWR VPWR sky130_fd_sc_hd__decap_3
XFILLER_42_282 VGND VGND VPWR VPWR sky130_fd_sc_hd__decap_3
XFILLER_15_496 VGND VGND VPWR VPWR sky130_fd_sc_hd__decap_3
XFILLER_30_477 VGND VGND VPWR VPWR sky130_fd_sc_hd__fill_1
XFILLER_30_499 VGND VGND VPWR VPWR sky130_fd_sc_hd__decap_3
XFILLER_11_691 VGND VGND VPWR VPWR sky130_fd_sc_hd__decap_3
X_3510_ _3330_/Y _3383_/B _3442_/B _5129_/B VGND VGND VPWR VPWR _3510_/X sky130_fd_sc_hd__a2bb2o_2
Xwire560 _3591_/Y VGND VGND VPWR VPWR wire560/X sky130_fd_sc_hd__buf_1
XFILLER_7_662 VGND VGND VPWR VPWR sky130_fd_sc_hd__decap_3
XFILLER_7_673 VGND VGND VPWR VPWR sky130_fd_sc_hd__decap_3
Xhold607 _6791_/Q VGND VGND VPWR VPWR _6791_/D sky130_fd_sc_hd__dlygate4sd3_1
XFILLER_116_527 VGND VGND VPWR VPWR sky130_fd_sc_hd__decap_3
Xhold618 _6956_/Q VGND VGND VPWR VPWR _6956_/D sky130_fd_sc_hd__dlygate4sd3_1
Xhold629 _6933_/Q VGND VGND VPWR VPWR _6933_/D sky130_fd_sc_hd__dlygate4sd3_1
X_3441_ _7058_/Q _4305_/B _3429_/X _3440_/X VGND VGND VPWR VPWR _3544_/A sky130_fd_sc_hd__o211ai_2
XFILLER_40_3 VGND VGND VPWR VPWR sky130_fd_sc_hd__fill_2
XTAP_TAPCELL_ROW_94_1493 VGND VPWR sky130_fd_sc_hd__tapvpwrvgnd_1
XFILLER_112_722 VGND VGND VPWR VPWR sky130_fd_sc_hd__decap_3
XFILLER_97_422 VGND VGND VPWR VPWR sky130_fd_sc_hd__decap_3
XFILLER_69_113 VGND VGND VPWR VPWR sky130_fd_sc_hd__decap_3
X_5111_ _3610_/A _3603_/Y _4292_/C _4948_/A VGND VGND VPWR VPWR _5111_/X sky130_fd_sc_hd__a31o_2
XFILLER_111_221 VGND VGND VPWR VPWR sky130_fd_sc_hd__decap_3
XFILLER_111_232 VGND VGND VPWR VPWR sky130_fd_sc_hd__decap_3
XFILLER_97_455 VGND VGND VPWR VPWR sky130_fd_sc_hd__decap_3
XFILLER_85_606 VGND VGND VPWR VPWR sky130_fd_sc_hd__decap_3
XFILLER_85_617 VGND VGND VPWR VPWR sky130_fd_sc_hd__decap_3
XFILLER_111_265 VGND VGND VPWR VPWR sky130_fd_sc_hd__decap_3
XFILLER_97_499 VGND VGND VPWR VPWR sky130_fd_sc_hd__decap_3
XFILLER_111_287 VGND VGND VPWR VPWR sky130_fd_sc_hd__decap_3
XFILLER_84_138 VGND VGND VPWR VPWR sky130_fd_sc_hd__fill_2
XFILLER_38_533 VGND VGND VPWR VPWR sky130_fd_sc_hd__fill_2
XFILLER_77_190 VGND VGND VPWR VPWR sky130_fd_sc_hd__decap_3
XFILLER_93_650 VGND VGND VPWR VPWR sky130_fd_sc_hd__decap_3
XFILLER_53_503 VGND VGND VPWR VPWR sky130_fd_sc_hd__fill_1
XFILLER_26_728 VGND VGND VPWR VPWR sky130_fd_sc_hd__decap_3
XFILLER_65_374 VGND VGND VPWR VPWR sky130_fd_sc_hd__decap_3
X_6993_ _7398_/CLK _6993_/D _6273_/Y VGND VGND VPWR VPWR _6993_/Q sky130_fd_sc_hd__dfrtp_2
XFILLER_93_694 VGND VGND VPWR VPWR sky130_fd_sc_hd__decap_3
XFILLER_92_171 VGND VGND VPWR VPWR sky130_fd_sc_hd__decap_3
XTAP_TAPCELL_ROW_36_734 VGND VPWR sky130_fd_sc_hd__tapvpwrvgnd_1
XFILLER_80_333 VGND VGND VPWR VPWR sky130_fd_sc_hd__decap_3
XFILLER_41_709 VGND VGND VPWR VPWR sky130_fd_sc_hd__decap_3
XTAP_TAPCELL_ROW_16_480 VGND VPWR sky130_fd_sc_hd__tapvpwrvgnd_1
X_4826_ _4826_/A _4826_/B VGND VGND VPWR VPWR _7001_/D sky130_fd_sc_hd__nor2_2
XFILLER_21_444 VGND VGND VPWR VPWR sky130_fd_sc_hd__decap_3
X_4757_ _4757_/A _4665_/X VGND VGND VPWR VPWR _4759_/A sky130_fd_sc_hd__or2b_2
XFILLER_119_332 VGND VGND VPWR VPWR sky130_fd_sc_hd__decap_3
XFILLER_119_343 VGND VGND VPWR VPWR sky130_fd_sc_hd__decap_3
X_3708_ _6801_/Q _3759_/A2 _3767_/A2 _6711_/Q _3707_/X VGND VGND VPWR VPWR _3708_/X
+ sky130_fd_sc_hd__a221o_2
X_4688_ _7001_/Q _7002_/Q _4687_/B _4690_/B VGND VGND VPWR VPWR _4688_/X sky130_fd_sc_hd__a31o_2
XFILLER_111_9 VGND VGND VPWR VPWR sky130_fd_sc_hd__decap_3
XFILLER_107_538 VGND VGND VPWR VPWR sky130_fd_sc_hd__decap_3
X_6427_ _6556_/A VGND VGND VPWR VPWR _6427_/Y sky130_fd_sc_hd__inv_2
XFILLER_108_23 VGND VGND VPWR VPWR sky130_fd_sc_hd__decap_3
X_3639_ _3636_/Y _4948_/A _3505_/X _5020_/A _3638_/X VGND VGND VPWR VPWR _3639_/X
+ sky130_fd_sc_hd__o221a_2
XFILLER_122_519 VGND VGND VPWR VPWR sky130_fd_sc_hd__decap_3
XFILLER_103_700 VGND VGND VPWR VPWR sky130_fd_sc_hd__decap_3
X_6358_ _6363_/A VGND VGND VPWR VPWR _6358_/Y sky130_fd_sc_hd__inv_2
XFILLER_68_38 VGND VGND VPWR VPWR sky130_fd_sc_hd__decap_3
XFILLER_115_582 VGND VGND VPWR VPWR sky130_fd_sc_hd__decap_3
XFILLER_0_326 VGND VGND VPWR VPWR sky130_fd_sc_hd__fill_1
X_6289_ _6366_/A VGND VGND VPWR VPWR _6289_/Y sky130_fd_sc_hd__inv_2
XFILLER_102_232 VGND VGND VPWR VPWR sky130_fd_sc_hd__fill_1
XFILLER_0_359 VGND VGND VPWR VPWR sky130_fd_sc_hd__decap_3
XFILLER_88_477 VGND VGND VPWR VPWR sky130_fd_sc_hd__fill_2
XFILLER_76_628 VGND VGND VPWR VPWR sky130_fd_sc_hd__decap_3
XFILLER_69_691 VGND VGND VPWR VPWR sky130_fd_sc_hd__decap_3
XFILLER_102_298 VGND VGND VPWR VPWR sky130_fd_sc_hd__decap_3
XFILLER_91_609 VGND VGND VPWR VPWR sky130_fd_sc_hd__decap_3
XFILLER_56_341 VGND VGND VPWR VPWR sky130_fd_sc_hd__decap_3
XFILLER_17_706 VGND VGND VPWR VPWR sky130_fd_sc_hd__decap_3
XFILLER_90_108 VGND VGND VPWR VPWR sky130_fd_sc_hd__decap_3
XFILLER_84_59 VGND VGND VPWR VPWR sky130_fd_sc_hd__decap_3
XFILLER_56_352 VGND VGND VPWR VPWR sky130_fd_sc_hd__decap_3
XFILLER_29_577 VGND VGND VPWR VPWR sky130_fd_sc_hd__decap_3
XFILLER_84_672 VGND VGND VPWR VPWR sky130_fd_sc_hd__decap_3
XFILLER_56_363 VGND VGND VPWR VPWR sky130_fd_sc_hd__fill_1
XFILLER_56_374 VGND VGND VPWR VPWR sky130_fd_sc_hd__decap_3
XFILLER_71_311 VGND VGND VPWR VPWR sky130_fd_sc_hd__fill_1
XFILLER_16_216 VGND VGND VPWR VPWR sky130_fd_sc_hd__decap_3
XFILLER_56_396 VGND VGND VPWR VPWR sky130_fd_sc_hd__decap_3
XFILLER_44_536 VGND VGND VPWR VPWR sky130_fd_sc_hd__fill_1
XFILLER_16_227 VGND VGND VPWR VPWR sky130_fd_sc_hd__decap_3
XFILLER_44_547 VGND VGND VPWR VPWR sky130_fd_sc_hd__decap_3
XFILLER_16_249 VGND VGND VPWR VPWR sky130_fd_sc_hd__decap_3
XFILLER_71_366 VGND VGND VPWR VPWR sky130_fd_sc_hd__decap_3
XFILLER_31_208 VGND VGND VPWR VPWR sky130_fd_sc_hd__fill_1
XFILLER_24_271 VGND VGND VPWR VPWR sky130_fd_sc_hd__decap_3
XFILLER_40_731 VGND VGND VPWR VPWR sky130_fd_sc_hd__decap_3
XFILLER_8_404 VGND VGND VPWR VPWR sky130_fd_sc_hd__decap_3
XFILLER_12_455 VGND VGND VPWR VPWR sky130_fd_sc_hd__decap_3
XFILLER_12_477 VGND VGND VPWR VPWR sky130_fd_sc_hd__decap_3
XPHY_EDGE_ROW_49_Left_173 VGND VGND VPWR VPWR sky130_fd_sc_hd__decap_3
XFILLER_4_610 VGND VGND VPWR VPWR sky130_fd_sc_hd__decap_3
XFILLER_99_709 VGND VGND VPWR VPWR sky130_fd_sc_hd__decap_3
XFILLER_4_643 VGND VGND VPWR VPWR sky130_fd_sc_hd__fill_1
XFILLER_4_654 VGND VGND VPWR VPWR sky130_fd_sc_hd__decap_3
XFILLER_113_508 VGND VGND VPWR VPWR sky130_fd_sc_hd__decap_3
XFILLER_106_560 VGND VGND VPWR VPWR sky130_fd_sc_hd__decap_3
XFILLER_79_411 VGND VGND VPWR VPWR sky130_fd_sc_hd__decap_3
XFILLER_4_687 VGND VGND VPWR VPWR sky130_fd_sc_hd__decap_3
XFILLER_121_541 VGND VGND VPWR VPWR sky130_fd_sc_hd__decap_3
XFILLER_67_606 VGND VGND VPWR VPWR sky130_fd_sc_hd__decap_3
XFILLER_67_617 VGND VGND VPWR VPWR sky130_fd_sc_hd__decap_3
XFILLER_79_488 VGND VGND VPWR VPWR sky130_fd_sc_hd__decap_3
XFILLER_121_585 VGND VGND VPWR VPWR sky130_fd_sc_hd__decap_3
XPHY_EDGE_ROW_58_Left_182 VGND VGND VPWR VPWR sky130_fd_sc_hd__decap_3
XFILLER_94_436 VGND VGND VPWR VPWR sky130_fd_sc_hd__decap_3
XFILLER_59_190 VGND VGND VPWR VPWR sky130_fd_sc_hd__decap_3
XFILLER_75_650 VGND VGND VPWR VPWR sky130_fd_sc_hd__decap_3
XFILLER_75_694 VGND VGND VPWR VPWR sky130_fd_sc_hd__decap_3
XFILLER_74_171 VGND VGND VPWR VPWR sky130_fd_sc_hd__decap_3
XFILLER_90_631 VGND VGND VPWR VPWR sky130_fd_sc_hd__decap_3
XFILLER_23_709 VGND VGND VPWR VPWR sky130_fd_sc_hd__decap_3
XFILLER_90_675 VGND VGND VPWR VPWR sky130_fd_sc_hd__decap_3
XFILLER_62_388 VGND VGND VPWR VPWR sky130_fd_sc_hd__fill_1
XFILLER_22_219 VGND VGND VPWR VPWR sky130_fd_sc_hd__decap_3
X_5660_ _5660_/A _5660_/B _5660_/C _5660_/D VGND VGND VPWR VPWR _5661_/D sky130_fd_sc_hd__and4_2
XPHY_EDGE_ROW_67_Left_191 VGND VGND VPWR VPWR sky130_fd_sc_hd__decap_3
XFILLER_90_80 VGND VGND VPWR VPWR sky130_fd_sc_hd__decap_3
X_4611_ _4611_/A VGND VGND VPWR VPWR _4611_/Y sky130_fd_sc_hd__inv_2
XFILLER_30_274 VGND VGND VPWR VPWR sky130_fd_sc_hd__decap_3
X_5591_ _5591_/A _5595_/B VGND VGND VPWR VPWR _7032_/D sky130_fd_sc_hd__or2_2
XFILLER_30_285 VGND VGND VPWR VPWR sky130_fd_sc_hd__decap_3
XTAP_TAPCELL_ROW_96_1511 VGND VPWR sky130_fd_sc_hd__tapvpwrvgnd_1
X_7330_ _7365_/CLK _7330_/D _6610_/Y VGND VGND VPWR VPWR _7330_/Q sky130_fd_sc_hd__dfrtp_2
X_4542_ _7309_/Q _4559_/B VGND VGND VPWR VPWR _7309_/D sky130_fd_sc_hd__and2_2
X_7261_ _7392_/CLK _7261_/D _6541_/Y VGND VGND VPWR VPWR _7261_/Q sky130_fd_sc_hd__dfrtp_2
XFILLER_116_368 VGND VGND VPWR VPWR sky130_fd_sc_hd__decap_3
X_3424_ _3398_/Y _3419_/Y _3424_/S VGND VGND VPWR VPWR _3590_/C sky130_fd_sc_hd__mux2_4
XFILLER_89_219 VGND VGND VPWR VPWR sky130_fd_sc_hd__decap_3
X_7192_ _7345_/CLK _7192_/D _6472_/Y VGND VGND VPWR VPWR _7192_/Q sky130_fd_sc_hd__dfrtp_2
XFILLER_98_731 VGND VGND VPWR VPWR sky130_fd_sc_hd__decap_3
XPHY_EDGE_ROW_115_Right_115 VGND VGND VPWR VPWR sky130_fd_sc_hd__decap_3
X_3355_ _3371_/A _5668_/A _3519_/B VGND VGND VPWR VPWR _3355_/Y sky130_fd_sc_hd__o21ai_2
XFILLER_58_617 VGND VGND VPWR VPWR sky130_fd_sc_hd__decap_3
XFILLER_112_563 VGND VGND VPWR VPWR sky130_fd_sc_hd__decap_3
Xhold1104 _7386_/Q VGND VGND VPWR VPWR _3860_/A0 sky130_fd_sc_hd__dlygate4sd3_1
XFILLER_100_725 VGND VGND VPWR VPWR sky130_fd_sc_hd__decap_3
Xhold1115 _7321_/Q VGND VGND VPWR VPWR _4517_/A0 sky130_fd_sc_hd__dlygate4sd3_1
Xhold1126 _7133_/Q VGND VGND VPWR VPWR _5400_/A0 sky130_fd_sc_hd__dlygate4sd3_1
XFILLER_97_296 VGND VGND VPWR VPWR sky130_fd_sc_hd__decap_3
Xhold1137 _7168_/Q VGND VGND VPWR VPWR _5325_/A0 sky130_fd_sc_hd__dlygate4sd3_1
XFILLER_85_447 VGND VGND VPWR VPWR sky130_fd_sc_hd__fill_1
X_5025_ _6989_/Q _5044_/A _6990_/Q VGND VGND VPWR VPWR _5026_/B sky130_fd_sc_hd__a21oi_2
Xhold1148 _7322_/Q VGND VGND VPWR VPWR _4515_/A0 sky130_fd_sc_hd__dlygate4sd3_1
Xhold1159 _7290_/Q VGND VGND VPWR VPWR _4581_/A sky130_fd_sc_hd__dlygate4sd3_1
XFILLER_66_672 VGND VGND VPWR VPWR sky130_fd_sc_hd__decap_3
XFILLER_38_363 VGND VGND VPWR VPWR sky130_fd_sc_hd__fill_1
XFILLER_26_503 VGND VGND VPWR VPWR sky130_fd_sc_hd__decap_3
XFILLER_81_620 VGND VGND VPWR VPWR sky130_fd_sc_hd__decap_3
XFILLER_53_311 VGND VGND VPWR VPWR sky130_fd_sc_hd__decap_3
XFILLER_38_396 VGND VGND VPWR VPWR sky130_fd_sc_hd__decap_3
XFILLER_54_29 VGND VGND VPWR VPWR sky130_fd_sc_hd__decap_3
XFILLER_81_653 VGND VGND VPWR VPWR sky130_fd_sc_hd__decap_3
XFILLER_80_141 VGND VGND VPWR VPWR sky130_fd_sc_hd__decap_3
X_6976_ clkload5/A _6976_/D VGND VGND VPWR VPWR _6976_/Q sky130_fd_sc_hd__dfxtp_2
XFILLER_13_208 VGND VGND VPWR VPWR sky130_fd_sc_hd__decap_3
XFILLER_81_697 VGND VGND VPWR VPWR sky130_fd_sc_hd__decap_3
XFILLER_110_24 VGND VGND VPWR VPWR sky130_fd_sc_hd__decap_3
XFILLER_110_35 VGND VGND VPWR VPWR sky130_fd_sc_hd__decap_3
XFILLER_22_731 VGND VGND VPWR VPWR sky130_fd_sc_hd__decap_3
XTAP_TAPCELL_ROW_11_409 VGND VPWR sky130_fd_sc_hd__tapvpwrvgnd_1
XFILLER_21_252 VGND VGND VPWR VPWR sky130_fd_sc_hd__decap_3
X_4809_ _7002_/Q _4826_/A VGND VGND VPWR VPWR _7002_/D sky130_fd_sc_hd__xor2_2
XPHY_EDGE_ROW_17_Right_17 VGND VGND VPWR VPWR sky130_fd_sc_hd__decap_3
XFILLER_21_296 VGND VGND VPWR VPWR sky130_fd_sc_hd__decap_3
XFILLER_119_140 VGND VGND VPWR VPWR sky130_fd_sc_hd__decap_3
XFILLER_119_33 VGND VGND VPWR VPWR sky130_fd_sc_hd__decap_3
XFILLER_119_66 VGND VGND VPWR VPWR sky130_fd_sc_hd__decap_3
XFILLER_119_195 VGND VGND VPWR VPWR sky130_fd_sc_hd__fill_2
XFILLER_119_99 VGND VGND VPWR VPWR sky130_fd_sc_hd__decap_3
XFILLER_107_368 VGND VGND VPWR VPWR sky130_fd_sc_hd__fill_1
XTAP_TAPCELL_ROW_116_1780 VGND VPWR sky130_fd_sc_hd__tapvpwrvgnd_1
Xhold960 _7022_/Q VGND VGND VPWR VPWR _5611_/A sky130_fd_sc_hd__dlygate4sd3_1
Xhold971 _7024_/Q VGND VGND VPWR VPWR _5607_/A sky130_fd_sc_hd__dlygate4sd3_1
Xhold982 _7325_/Q VGND VGND VPWR VPWR hold982/X sky130_fd_sc_hd__dlygate4sd3_1
XFILLER_1_635 VGND VGND VPWR VPWR sky130_fd_sc_hd__decap_3
XFILLER_122_338 VGND VGND VPWR VPWR sky130_fd_sc_hd__decap_3
Xhold993 _7039_/Q VGND VGND VPWR VPWR hold993/X sky130_fd_sc_hd__dlygate4sd3_1
XFILLER_115_390 VGND VGND VPWR VPWR sky130_fd_sc_hd__fill_2
XFILLER_88_241 VGND VGND VPWR VPWR sky130_fd_sc_hd__decap_3
XFILLER_49_606 VGND VGND VPWR VPWR sky130_fd_sc_hd__decap_3
XFILLER_1_668 VGND VGND VPWR VPWR sky130_fd_sc_hd__decap_3
XFILLER_49_617 VGND VGND VPWR VPWR sky130_fd_sc_hd__decap_3
XFILLER_1_679 VGND VGND VPWR VPWR sky130_fd_sc_hd__decap_3
XFILLER_0_167 VGND VGND VPWR VPWR sky130_fd_sc_hd__fill_1
XFILLER_88_274 VGND VGND VPWR VPWR sky130_fd_sc_hd__decap_3
XFILLER_103_585 VGND VGND VPWR VPWR sky130_fd_sc_hd__decap_3
XPHY_EDGE_ROW_26_Right_26 VGND VGND VPWR VPWR sky130_fd_sc_hd__decap_3
XFILLER_95_47 VGND VGND VPWR VPWR sky130_fd_sc_hd__fill_1
XFILLER_95_69 VGND VGND VPWR VPWR sky130_fd_sc_hd__decap_3
XFILLER_57_650 VGND VGND VPWR VPWR sky130_fd_sc_hd__decap_3
XTAP_TAPCELL_ROW_19_509 VGND VPWR sky130_fd_sc_hd__tapvpwrvgnd_1
XFILLER_63_119 VGND VGND VPWR VPWR sky130_fd_sc_hd__decap_3
XFILLER_29_374 VGND VGND VPWR VPWR sky130_fd_sc_hd__decap_3
XFILLER_17_514 VGND VGND VPWR VPWR sky130_fd_sc_hd__decap_3
XFILLER_57_694 VGND VGND VPWR VPWR sky130_fd_sc_hd__decap_3
XFILLER_29_396 VGND VGND VPWR VPWR sky130_fd_sc_hd__decap_3
XTAP_TAPCELL_ROW_67_1134 VGND VPWR sky130_fd_sc_hd__tapvpwrvgnd_1
XFILLER_72_631 VGND VGND VPWR VPWR sky130_fd_sc_hd__decap_3
XFILLER_71_130 VGND VGND VPWR VPWR sky130_fd_sc_hd__decap_3
XFILLER_72_675 VGND VGND VPWR VPWR sky130_fd_sc_hd__decap_3
XFILLER_71_163 VGND VGND VPWR VPWR sky130_fd_sc_hd__decap_3
XFILLER_44_377 VGND VGND VPWR VPWR sky130_fd_sc_hd__fill_2
XTAP_TAPCELL_ROW_80_1301 VGND VPWR sky130_fd_sc_hd__tapvpwrvgnd_1
XTAP_TAPCELL_ROW_80_1312 VGND VPWR sky130_fd_sc_hd__tapvpwrvgnd_1
XFILLER_25_591 VGND VGND VPWR VPWR sky130_fd_sc_hd__decap_3
XPHY_EDGE_ROW_35_Right_35 VGND VGND VPWR VPWR sky130_fd_sc_hd__decap_3
XFILLER_9_724 VGND VGND VPWR VPWR sky130_fd_sc_hd__decap_3
XTAP_TAPCELL_ROW_119_1809 VGND VPWR sky130_fd_sc_hd__tapvpwrvgnd_1
XFILLER_12_285 VGND VGND VPWR VPWR sky130_fd_sc_hd__decap_3
XFILLER_74_9 VGND VGND VPWR VPWR sky130_fd_sc_hd__decap_3
XFILLER_8_256 VGND VGND VPWR VPWR sky130_fd_sc_hd__decap_3
XFILLER_60_83 VGND VGND VPWR VPWR sky130_fd_sc_hd__fill_1
Xoutput509 _5648_/A VGND VGND VPWR VPWR instruction_out[27] sky130_fd_sc_hd__clkdlybuf4s25_1
XFILLER_4_440 VGND VGND VPWR VPWR sky130_fd_sc_hd__decap_3
XTAP_TAPCELL_ROW_78_1285 VGND VPWR sky130_fd_sc_hd__tapvpwrvgnd_1
XFILLER_4_462 VGND VGND VPWR VPWR sky130_fd_sc_hd__fill_1
XFILLER_4_473 VGND VGND VPWR VPWR sky130_fd_sc_hd__decap_3
XFILLER_4_484 VGND VGND VPWR VPWR sky130_fd_sc_hd__fill_1
XTAP_TAPCELL_ROW_91_1452 VGND VPWR sky130_fd_sc_hd__tapvpwrvgnd_1
XPHY_EDGE_ROW_44_Right_44 VGND VGND VPWR VPWR sky130_fd_sc_hd__decap_3
XFILLER_79_241 VGND VGND VPWR VPWR sky130_fd_sc_hd__decap_3
XFILLER_95_712 VGND VGND VPWR VPWR sky130_fd_sc_hd__decap_3
XFILLER_94_200 VGND VGND VPWR VPWR sky130_fd_sc_hd__decap_3
XFILLER_39_105 VGND VGND VPWR VPWR sky130_fd_sc_hd__decap_3
XFILLER_39_127 VGND VGND VPWR VPWR sky130_fd_sc_hd__fill_2
XFILLER_94_233 VGND VGND VPWR VPWR sky130_fd_sc_hd__decap_3
XFILLER_121_393 VGND VGND VPWR VPWR sky130_fd_sc_hd__fill_1
XFILLER_0_690 VGND VGND VPWR VPWR sky130_fd_sc_hd__decap_3
XFILLER_55_609 VGND VGND VPWR VPWR sky130_fd_sc_hd__decap_3
XFILLER_82_406 VGND VGND VPWR VPWR sky130_fd_sc_hd__decap_3
XFILLER_48_672 VGND VGND VPWR VPWR sky130_fd_sc_hd__decap_3
XFILLER_94_288 VGND VGND VPWR VPWR sky130_fd_sc_hd__decap_3
XFILLER_85_91 VGND VGND VPWR VPWR sky130_fd_sc_hd__decap_3
XFILLER_82_439 VGND VGND VPWR VPWR sky130_fd_sc_hd__decap_3
XFILLER_47_160 VGND VGND VPWR VPWR sky130_fd_sc_hd__decap_3
XFILLER_63_620 VGND VGND VPWR VPWR sky130_fd_sc_hd__decap_3
XFILLER_35_311 VGND VGND VPWR VPWR sky130_fd_sc_hd__decap_3
XFILLER_35_333 VGND VGND VPWR VPWR sky130_fd_sc_hd__decap_3
XFILLER_63_653 VGND VGND VPWR VPWR sky130_fd_sc_hd__decap_3
X_6830_ _7380_/CLK _6830_/D VGND VGND VPWR VPWR _6830_/Q sky130_fd_sc_hd__dfxtp_2
XFILLER_35_355 VGND VGND VPWR VPWR sky130_fd_sc_hd__decap_3
XFILLER_62_141 VGND VGND VPWR VPWR sky130_fd_sc_hd__decap_3
XTAP_TAPCELL_ROW_46_862 VGND VPWR sky130_fd_sc_hd__tapvpwrvgnd_1
XFILLER_62_163 VGND VGND VPWR VPWR sky130_fd_sc_hd__decap_3
XFILLER_63_697 VGND VGND VPWR VPWR sky130_fd_sc_hd__decap_3
X_6761_ _7380_/CLK _6761_/D VGND VGND VPWR VPWR _6761_/Q sky130_fd_sc_hd__dfxtp_2
XFILLER_35_399 VGND VGND VPWR VPWR sky130_fd_sc_hd__decap_3
XPHY_EDGE_ROW_53_Right_53 VGND VGND VPWR VPWR sky130_fd_sc_hd__decap_3
X_3973_ _7354_/Q _4515_/A0 _3975_/S VGND VGND VPWR VPWR _7354_/D sky130_fd_sc_hd__mux2_2
XFILLER_90_494 VGND VGND VPWR VPWR sky130_fd_sc_hd__fill_1
XFILLER_50_336 VGND VGND VPWR VPWR sky130_fd_sc_hd__decap_3
X_5712_ _7362_/Q hold906/X _5712_/S VGND VGND VPWR VPWR _6706_/D sky130_fd_sc_hd__mux2_2
X_6692_ _7378_/CLK _6692_/D VGND VGND VPWR VPWR _6692_/Q sky130_fd_sc_hd__dfxtp_2
X_5643_ _5643_/A VGND VGND VPWR VPWR _5643_/X sky130_fd_sc_hd__buf_1
XFILLER_31_594 VGND VGND VPWR VPWR sky130_fd_sc_hd__decap_3
XTAP_TAPCELL_ROW_100_1570 VGND VPWR sky130_fd_sc_hd__tapvpwrvgnd_1
XFILLER_117_600 VGND VGND VPWR VPWR sky130_fd_sc_hd__decap_3
X_5574_ hold935/X _5587_/B _4983_/X VGND VGND VPWR VPWR _7043_/D sky130_fd_sc_hd__a21o_2
X_7313_ _7313_/CLK _7313_/D _6593_/Y VGND VGND VPWR VPWR _7313_/Q sky130_fd_sc_hd__dfrtp_2
XFILLER_117_644 VGND VGND VPWR VPWR sky130_fd_sc_hd__decap_3
XFILLER_117_688 VGND VGND VPWR VPWR sky130_fd_sc_hd__decap_3
X_7244_ _7372_/CLK _7244_/D _6524_/Y VGND VGND VPWR VPWR _7244_/Q sky130_fd_sc_hd__dfrtp_2
XFILLER_116_165 VGND VGND VPWR VPWR sky130_fd_sc_hd__fill_1
X_4456_ _4456_/A _4054_/A VGND VGND VPWR VPWR _4456_/X sky130_fd_sc_hd__or2b_2
XPHY_EDGE_ROW_62_Right_62 VGND VGND VPWR VPWR sky130_fd_sc_hd__decap_3
XFILLER_116_187 VGND VGND VPWR VPWR sky130_fd_sc_hd__decap_3
XFILLER_104_338 VGND VGND VPWR VPWR sky130_fd_sc_hd__decap_3
X_3407_ _3421_/B _3421_/C _3417_/C VGND VGND VPWR VPWR _3407_/X sky130_fd_sc_hd__and3_2
X_7175_ _7399_/CLK _7175_/D _6455_/Y VGND VGND VPWR VPWR _7175_/Q sky130_fd_sc_hd__dfrtp_2
X_4387_ _7241_/Q _4430_/A2 _4430_/B1 _7177_/Q _4386_/X VGND VGND VPWR VPWR _4387_/X
+ sky130_fd_sc_hd__a221o_2
XFILLER_98_550 VGND VGND VPWR VPWR sky130_fd_sc_hd__decap_3
XFILLER_86_701 VGND VGND VPWR VPWR sky130_fd_sc_hd__decap_3
XFILLER_98_583 VGND VGND VPWR VPWR sky130_fd_sc_hd__decap_3
XFILLER_86_734 VGND VGND VPWR VPWR sky130_fd_sc_hd__fill_1
XFILLER_105_24 VGND VGND VPWR VPWR sky130_fd_sc_hd__decap_3
XFILLER_85_222 VGND VGND VPWR VPWR sky130_fd_sc_hd__fill_2
XFILLER_58_436 VGND VGND VPWR VPWR sky130_fd_sc_hd__decap_3
XFILLER_112_393 VGND VGND VPWR VPWR sky130_fd_sc_hd__decap_3
XFILLER_100_533 VGND VGND VPWR VPWR sky130_fd_sc_hd__decap_3
XFILLER_85_244 VGND VGND VPWR VPWR sky130_fd_sc_hd__decap_3
XFILLER_39_650 VGND VGND VPWR VPWR sky130_fd_sc_hd__decap_3
XFILLER_65_28 VGND VGND VPWR VPWR sky130_fd_sc_hd__decap_3
XFILLER_100_577 VGND VGND VPWR VPWR sky130_fd_sc_hd__decap_3
XFILLER_85_277 VGND VGND VPWR VPWR sky130_fd_sc_hd__decap_3
XFILLER_45_108 VGND VGND VPWR VPWR sky130_fd_sc_hd__decap_3
X_5008_ _4680_/A _5015_/B _5587_/B VGND VGND VPWR VPWR _5009_/B sky130_fd_sc_hd__a21o_2
XFILLER_38_160 VGND VGND VPWR VPWR sky130_fd_sc_hd__decap_3
XFILLER_85_299 VGND VGND VPWR VPWR sky130_fd_sc_hd__decap_3
XFILLER_66_480 VGND VGND VPWR VPWR sky130_fd_sc_hd__decap_3
XFILLER_39_694 VGND VGND VPWR VPWR sky130_fd_sc_hd__decap_3
XFILLER_54_631 VGND VGND VPWR VPWR sky130_fd_sc_hd__decap_3
XFILLER_26_333 VGND VGND VPWR VPWR sky130_fd_sc_hd__decap_3
XFILLER_121_12 VGND VGND VPWR VPWR sky130_fd_sc_hd__decap_3
XPHY_EDGE_ROW_71_Right_71 VGND VGND VPWR VPWR sky130_fd_sc_hd__decap_3
XFILLER_81_461 VGND VGND VPWR VPWR sky130_fd_sc_hd__decap_3
XFILLER_54_675 VGND VGND VPWR VPWR sky130_fd_sc_hd__decap_3
XFILLER_121_45 VGND VGND VPWR VPWR sky130_fd_sc_hd__decap_3
XFILLER_26_377 VGND VGND VPWR VPWR sky130_fd_sc_hd__decap_3
XFILLER_81_472 VGND VGND VPWR VPWR sky130_fd_sc_hd__decap_3
XFILLER_53_163 VGND VGND VPWR VPWR sky130_fd_sc_hd__decap_3
XFILLER_121_78 VGND VGND VPWR VPWR sky130_fd_sc_hd__decap_3
X_6959_ _6965_/CLK _6959_/D VGND VGND VPWR VPWR _6959_/Q sky130_fd_sc_hd__dfxtp_2
XFILLER_81_38 VGND VGND VPWR VPWR sky130_fd_sc_hd__fill_1
XFILLER_53_196 VGND VGND VPWR VPWR sky130_fd_sc_hd__decap_3
XFILLER_10_701 VGND VGND VPWR VPWR sky130_fd_sc_hd__decap_3
XTAP_TAPCELL_ROW_24_578 VGND VPWR sky130_fd_sc_hd__tapvpwrvgnd_1
XTAP_TAPCELL_ROW_62_1075 VGND VPWR sky130_fd_sc_hd__tapvpwrvgnd_1
XFILLER_22_572 VGND VGND VPWR VPWR sky130_fd_sc_hd__decap_3
XFILLER_10_734 VGND VGND VPWR VPWR sky130_fd_sc_hd__fill_1
XFILLER_6_716 VGND VGND VPWR VPWR sky130_fd_sc_hd__decap_3
XFILLER_108_622 VGND VGND VPWR VPWR sky130_fd_sc_hd__decap_3
XFILLER_108_666 VGND VGND VPWR VPWR sky130_fd_sc_hd__decap_3
XPHY_EDGE_ROW_80_Right_80 VGND VGND VPWR VPWR sky130_fd_sc_hd__decap_3
XFILLER_30_64 VGND VGND VPWR VPWR sky130_fd_sc_hd__decap_3
XFILLER_107_143 VGND VGND VPWR VPWR sky130_fd_sc_hd__decap_3
XFILLER_123_614 VGND VGND VPWR VPWR sky130_fd_sc_hd__fill_2
XFILLER_108_699 VGND VGND VPWR VPWR sky130_fd_sc_hd__fill_1
XFILLER_107_187 VGND VGND VPWR VPWR sky130_fd_sc_hd__decap_3
Xhold790 _6878_/Q VGND VGND VPWR VPWR _6878_/D sky130_fd_sc_hd__dlygate4sd3_1
XFILLER_89_550 VGND VGND VPWR VPWR sky130_fd_sc_hd__decap_3
XFILLER_89_561 VGND VGND VPWR VPWR sky130_fd_sc_hd__decap_3
XFILLER_77_712 VGND VGND VPWR VPWR sky130_fd_sc_hd__decap_3
XFILLER_76_200 VGND VGND VPWR VPWR sky130_fd_sc_hd__fill_2
XFILLER_89_594 VGND VGND VPWR VPWR sky130_fd_sc_hd__decap_3
XFILLER_103_371 VGND VGND VPWR VPWR sky130_fd_sc_hd__fill_1
XFILLER_103_393 VGND VGND VPWR VPWR sky130_fd_sc_hd__decap_3
XFILLER_37_609 VGND VGND VPWR VPWR sky130_fd_sc_hd__decap_3
XFILLER_92_704 VGND VGND VPWR VPWR sky130_fd_sc_hd__decap_3
XFILLER_91_225 VGND VGND VPWR VPWR sky130_fd_sc_hd__decap_3
XFILLER_45_620 VGND VGND VPWR VPWR sky130_fd_sc_hd__decap_3
XFILLER_29_182 VGND VGND VPWR VPWR sky130_fd_sc_hd__decap_3
XFILLER_17_333 VGND VGND VPWR VPWR sky130_fd_sc_hd__decap_3
XFILLER_91_258 VGND VGND VPWR VPWR sky130_fd_sc_hd__decap_3
XFILLER_45_653 VGND VGND VPWR VPWR sky130_fd_sc_hd__decap_3
XFILLER_17_355 VGND VGND VPWR VPWR sky130_fd_sc_hd__decap_3
XFILLER_32_303 VGND VGND VPWR VPWR sky130_fd_sc_hd__decap_3
XFILLER_45_697 VGND VGND VPWR VPWR sky130_fd_sc_hd__decap_3
XFILLER_17_388 VGND VGND VPWR VPWR sky130_fd_sc_hd__decap_3
XTAP_TAPCELL_ROW_43_821 VGND VPWR sky130_fd_sc_hd__tapvpwrvgnd_1
XFILLER_60_634 VGND VGND VPWR VPWR sky130_fd_sc_hd__decap_3
XTAP_TAPCELL_ROW_43_832 VGND VPWR sky130_fd_sc_hd__tapvpwrvgnd_1
XFILLER_60_645 VGND VGND VPWR VPWR sky130_fd_sc_hd__decap_3
XFILLER_60_678 VGND VGND VPWR VPWR sky130_fd_sc_hd__decap_3
XFILLER_13_561 VGND VGND VPWR VPWR sky130_fd_sc_hd__decap_3
XFILLER_71_60 VGND VGND VPWR VPWR sky130_fd_sc_hd__decap_3
XFILLER_13_594 VGND VGND VPWR VPWR sky130_fd_sc_hd__decap_3
XFILLER_9_576 VGND VGND VPWR VPWR sky130_fd_sc_hd__decap_3
X_4310_ _7352_/Q _4270_/B _4352_/B1 _7160_/Q VGND VGND VPWR VPWR _4311_/C sky130_fd_sc_hd__a22o_2
XFILLER_99_314 VGND VGND VPWR VPWR sky130_fd_sc_hd__decap_3
XFILLER_114_625 VGND VGND VPWR VPWR sky130_fd_sc_hd__decap_3
X_5290_ _5290_/A0 _5156_/X _5292_/S VGND VGND VPWR VPWR _7184_/D sky130_fd_sc_hd__mux2_2
XFILLER_113_113 VGND VGND VPWR VPWR sky130_fd_sc_hd__decap_3
XFILLER_4_281 VGND VGND VPWR VPWR sky130_fd_sc_hd__fill_1
X_4241_ _5018_/B _4241_/B VGND VGND VPWR VPWR _5032_/A sky130_fd_sc_hd__or2_2
XFILLER_114_669 VGND VGND VPWR VPWR sky130_fd_sc_hd__decap_3
XFILLER_68_701 VGND VGND VPWR VPWR sky130_fd_sc_hd__decap_3
X_4172_ _4938_/B _4379_/B VGND VGND VPWR VPWR _4936_/A sky130_fd_sc_hd__nor2_2
XFILLER_68_734 VGND VGND VPWR VPWR sky130_fd_sc_hd__fill_1
XFILLER_67_211 VGND VGND VPWR VPWR sky130_fd_sc_hd__decap_3
XFILLER_67_233 VGND VGND VPWR VPWR sky130_fd_sc_hd__decap_3
XFILLER_95_564 VGND VGND VPWR VPWR sky130_fd_sc_hd__decap_3
XFILLER_83_715 VGND VGND VPWR VPWR sky130_fd_sc_hd__decap_3
XFILLER_67_266 VGND VGND VPWR VPWR sky130_fd_sc_hd__decap_3
XFILLER_82_203 VGND VGND VPWR VPWR sky130_fd_sc_hd__decap_3
XFILLER_55_417 VGND VGND VPWR VPWR sky130_fd_sc_hd__decap_3
XFILLER_95_597 VGND VGND VPWR VPWR sky130_fd_sc_hd__decap_3
XFILLER_27_119 VGND VGND VPWR VPWR sky130_fd_sc_hd__decap_3
XFILLER_48_480 VGND VGND VPWR VPWR sky130_fd_sc_hd__fill_1
XFILLER_36_631 VGND VGND VPWR VPWR sky130_fd_sc_hd__decap_3
XFILLER_63_461 VGND VGND VPWR VPWR sky130_fd_sc_hd__decap_3
XFILLER_51_601 VGND VGND VPWR VPWR sky130_fd_sc_hd__decap_3
XFILLER_36_675 VGND VGND VPWR VPWR sky130_fd_sc_hd__decap_3
XFILLER_51_623 VGND VGND VPWR VPWR sky130_fd_sc_hd__decap_3
XFILLER_23_314 VGND VGND VPWR VPWR sky130_fd_sc_hd__decap_3
X_6813_ clkload8/A _6813_/D VGND VGND VPWR VPWR _6813_/Q sky130_fd_sc_hd__dfxtp_2
Xplace450 _3561_/B VGND VGND VPWR VPWR _5670_/A sky130_fd_sc_hd__buf_2
XFILLER_50_100 VGND VGND VPWR VPWR sky130_fd_sc_hd__fill_1
XFILLER_63_494 VGND VGND VPWR VPWR sky130_fd_sc_hd__decap_3
XFILLER_51_656 VGND VGND VPWR VPWR sky130_fd_sc_hd__decap_3
XFILLER_50_144 VGND VGND VPWR VPWR sky130_fd_sc_hd__fill_2
X_3956_ _7362_/Q _4499_/A0 _3956_/S VGND VGND VPWR VPWR _7362_/D sky130_fd_sc_hd__mux2_2
X_6744_ clkload7/A _6744_/D VGND VGND VPWR VPWR _6744_/Q sky130_fd_sc_hd__dfxtp_2
XFILLER_50_166 VGND VGND VPWR VPWR sky130_fd_sc_hd__decap_3
XTAP_TAPCELL_ROW_21_537 VGND VPWR sky130_fd_sc_hd__tapvpwrvgnd_1
X_6675_ _6684_/A VGND VGND VPWR VPWR _6675_/Y sky130_fd_sc_hd__inv_2
XFILLER_31_380 VGND VGND VPWR VPWR sky130_fd_sc_hd__decap_3
X_3887_ _6694_/Q _5660_/B _3665_/X _6872_/Q _3886_/X VGND VGND VPWR VPWR _3887_/X
+ sky130_fd_sc_hd__a221o_2
XFILLER_109_408 VGND VGND VPWR VPWR sky130_fd_sc_hd__fill_2
X_5626_ _5626_/A _5634_/B VGND VGND VPWR VPWR _7015_/D sky130_fd_sc_hd__and2_2
XFILLER_105_603 VGND VGND VPWR VPWR sky130_fd_sc_hd__decap_3
XFILLER_2_218 VGND VGND VPWR VPWR sky130_fd_sc_hd__fill_2
XFILLER_117_485 VGND VGND VPWR VPWR sky130_fd_sc_hd__decap_3
XFILLER_105_647 VGND VGND VPWR VPWR sky130_fd_sc_hd__decap_3
X_4439_ _4440_/A _4650_/B VGND VGND VPWR VPWR _4813_/B sky130_fd_sc_hd__or2_2
X_7227_ _7354_/CLK _7227_/D _6507_/Y VGND VGND VPWR VPWR _7227_/Q sky130_fd_sc_hd__dfrtp_2
XFILLER_116_23 VGND VGND VPWR VPWR sky130_fd_sc_hd__decap_3
XFILLER_59_712 VGND VGND VPWR VPWR sky130_fd_sc_hd__decap_3
XFILLER_120_628 VGND VGND VPWR VPWR sky130_fd_sc_hd__decap_3
XFILLER_116_56 VGND VGND VPWR VPWR sky130_fd_sc_hd__decap_3
X_7158_ _7352_/CLK _7158_/D _6438_/Y VGND VGND VPWR VPWR _7158_/Q sky130_fd_sc_hd__dfrtp_2
XFILLER_86_531 VGND VGND VPWR VPWR sky130_fd_sc_hd__fill_1
XFILLER_113_691 VGND VGND VPWR VPWR sky130_fd_sc_hd__decap_3
XFILLER_74_704 VGND VGND VPWR VPWR sky130_fd_sc_hd__decap_3
XFILLER_19_609 VGND VGND VPWR VPWR sky130_fd_sc_hd__decap_3
X_7089_ _7313_/CLK _7089_/D _6369_/Y VGND VGND VPWR VPWR _7089_/Q sky130_fd_sc_hd__dfstp_2
XFILLER_86_586 VGND VGND VPWR VPWR sky130_fd_sc_hd__fill_2
XFILLER_73_203 VGND VGND VPWR VPWR sky130_fd_sc_hd__decap_3
XFILLER_73_225 VGND VGND VPWR VPWR sky130_fd_sc_hd__decap_3
XFILLER_27_620 VGND VGND VPWR VPWR sky130_fd_sc_hd__decap_3
XTAP_TAPCELL_ROW_29_648 VGND VPWR sky130_fd_sc_hd__tapvpwrvgnd_1
XFILLER_73_258 VGND VGND VPWR VPWR sky130_fd_sc_hd__decap_3
XFILLER_61_409 VGND VGND VPWR VPWR sky130_fd_sc_hd__decap_3
XFILLER_27_653 VGND VGND VPWR VPWR sky130_fd_sc_hd__decap_3
XFILLER_26_130 VGND VGND VPWR VPWR sky130_fd_sc_hd__decap_3
XFILLER_26_141 VGND VGND VPWR VPWR sky130_fd_sc_hd__decap_3
XFILLER_92_48 VGND VGND VPWR VPWR sky130_fd_sc_hd__decap_3
XFILLER_42_601 VGND VGND VPWR VPWR sky130_fd_sc_hd__decap_3
XTAP_TAPCELL_ROW_1_284 VGND VPWR sky130_fd_sc_hd__tapvpwrvgnd_1
XTAP_TAPCELL_ROW_64_1104 VGND VPWR sky130_fd_sc_hd__tapvpwrvgnd_1
XFILLER_27_697 VGND VGND VPWR VPWR sky130_fd_sc_hd__decap_3
XFILLER_42_634 VGND VGND VPWR VPWR sky130_fd_sc_hd__decap_3
XFILLER_42_645 VGND VGND VPWR VPWR sky130_fd_sc_hd__decap_3
XFILLER_42_678 VGND VGND VPWR VPWR sky130_fd_sc_hd__decap_3
XFILLER_25_86 VGND VGND VPWR VPWR sky130_fd_sc_hd__decap_3
XFILLER_41_166 VGND VGND VPWR VPWR sky130_fd_sc_hd__fill_2
XFILLER_10_520 VGND VGND VPWR VPWR sky130_fd_sc_hd__fill_1
XFILLER_10_542 VGND VGND VPWR VPWR sky130_fd_sc_hd__decap_3
XFILLER_10_575 VGND VGND VPWR VPWR sky130_fd_sc_hd__decap_3
XFILLER_6_557 VGND VGND VPWR VPWR sky130_fd_sc_hd__decap_3
XTAP_TAPCELL_ROW_75_1244 VGND VPWR sky130_fd_sc_hd__tapvpwrvgnd_1
XFILLER_111_606 VGND VGND VPWR VPWR sky130_fd_sc_hd__decap_3
XFILLER_111_617 VGND VGND VPWR VPWR sky130_fd_sc_hd__decap_3
XTAP_TAPCELL_ROW_9_384 VGND VPWR sky130_fd_sc_hd__tapvpwrvgnd_1
XFILLER_123_488 VGND VGND VPWR VPWR sky130_fd_sc_hd__decap_3
XFILLER_89_391 VGND VGND VPWR VPWR sky130_fd_sc_hd__fill_1
XFILLER_2_24 VGND VGND VPWR VPWR sky130_fd_sc_hd__decap_3
XFILLER_1_284 VGND VGND VPWR VPWR sky130_fd_sc_hd__decap_3
XFILLER_2_35 VGND VGND VPWR VPWR sky130_fd_sc_hd__fill_1
XFILLER_1_295 VGND VGND VPWR VPWR sky130_fd_sc_hd__fill_1
XFILLER_77_553 VGND VGND VPWR VPWR sky130_fd_sc_hd__decap_3
XFILLER_49_255 VGND VGND VPWR VPWR sky130_fd_sc_hd__decap_3
XFILLER_65_715 VGND VGND VPWR VPWR sky130_fd_sc_hd__decap_3
XFILLER_64_203 VGND VGND VPWR VPWR sky130_fd_sc_hd__decap_3
XFILLER_77_597 VGND VGND VPWR VPWR sky130_fd_sc_hd__decap_3
XFILLER_49_299 VGND VGND VPWR VPWR sky130_fd_sc_hd__decap_3
XFILLER_64_236 VGND VGND VPWR VPWR sky130_fd_sc_hd__decap_3
XFILLER_18_631 VGND VGND VPWR VPWR sky130_fd_sc_hd__decap_3
XFILLER_92_556 VGND VGND VPWR VPWR sky130_fd_sc_hd__decap_3
XFILLER_66_93 VGND VGND VPWR VPWR sky130_fd_sc_hd__fill_2
XFILLER_80_707 VGND VGND VPWR VPWR sky130_fd_sc_hd__decap_3
XFILLER_92_589 VGND VGND VPWR VPWR sky130_fd_sc_hd__decap_3
XFILLER_18_675 VGND VGND VPWR VPWR sky130_fd_sc_hd__decap_3
XTAP_TAPCELL_ROW_86_1384 VGND VPWR sky130_fd_sc_hd__tapvpwrvgnd_1
XFILLER_33_623 VGND VGND VPWR VPWR sky130_fd_sc_hd__decap_3
XTAP_TAPCELL_ROW_56_990 VGND VPWR sky130_fd_sc_hd__tapvpwrvgnd_1
XFILLER_17_185 VGND VGND VPWR VPWR sky130_fd_sc_hd__fill_2
XFILLER_72_291 VGND VGND VPWR VPWR sky130_fd_sc_hd__decap_3
XFILLER_33_656 VGND VGND VPWR VPWR sky130_fd_sc_hd__decap_3
X_3810_ _6846_/Q _3886_/A2 _3890_/B1 _6831_/Q _3809_/X VGND VGND VPWR VPWR _3810_/X
+ sky130_fd_sc_hd__a221o_2
XFILLER_32_155 VGND VGND VPWR VPWR sky130_fd_sc_hd__decap_3
X_4790_ _4781_/X _4782_/Y _4787_/Y _4829_/A _4789_/X VGND VGND VPWR VPWR _5664_/A
+ sky130_fd_sc_hd__o221a_2
XFILLER_60_475 VGND VGND VPWR VPWR sky130_fd_sc_hd__fill_1
XFILLER_20_317 VGND VGND VPWR VPWR sky130_fd_sc_hd__fill_2
X_3741_ _3746_/A _3741_/B _3746_/C VGND VGND VPWR VPWR _3741_/X sky130_fd_sc_hd__and3_4
XFILLER_13_380 VGND VGND VPWR VPWR sky130_fd_sc_hd__decap_3
XFILLER_119_706 VGND VGND VPWR VPWR sky130_fd_sc_hd__decap_3
XFILLER_9_340 VGND VGND VPWR VPWR sky130_fd_sc_hd__fill_1
XFILLER_9_362 VGND VGND VPWR VPWR sky130_fd_sc_hd__decap_3
X_6460_ _6619_/A VGND VGND VPWR VPWR _6460_/Y sky130_fd_sc_hd__inv_2
XFILLER_70_3 VGND VGND VPWR VPWR sky130_fd_sc_hd__decap_3
X_3672_ _3746_/A _3746_/B _3733_/C VGND VGND VPWR VPWR _3672_/X sky130_fd_sc_hd__or3_2
XFILLER_118_227 VGND VGND VPWR VPWR sky130_fd_sc_hd__decap_3
XFILLER_9_384 VGND VGND VPWR VPWR sky130_fd_sc_hd__decap_3
X_5411_ _5411_/A0 _5094_/X _5427_/S VGND VGND VPWR VPWR _7128_/D sky130_fd_sc_hd__mux2_2
X_6391_ _6557_/A VGND VGND VPWR VPWR _6391_/Y sky130_fd_sc_hd__inv_2
X_5342_ _5342_/A0 _5094_/X _5344_/S VGND VGND VPWR VPWR _7160_/D sky130_fd_sc_hd__mux2_2
XFILLER_114_455 VGND VGND VPWR VPWR sky130_fd_sc_hd__decap_3
XFILLER_99_166 VGND VGND VPWR VPWR sky130_fd_sc_hd__fill_2
X_7012_ _7354_/CLK _7012_/D _6292_/Y VGND VGND VPWR VPWR _7012_/Q sky130_fd_sc_hd__dfrtp_2
XFILLER_102_628 VGND VGND VPWR VPWR sky130_fd_sc_hd__decap_3
X_4224_ _4371_/A _4371_/B _4224_/C VGND VGND VPWR VPWR _4372_/A sky130_fd_sc_hd__and3_2
XFILLER_99_199 VGND VGND VPWR VPWR sky130_fd_sc_hd__decap_3
XFILLER_101_116 VGND VGND VPWR VPWR sky130_fd_sc_hd__decap_3
X_4155_ _4151_/X _4154_/X _4425_/A VGND VGND VPWR VPWR _4205_/C sky130_fd_sc_hd__o21ai_2
XFILLER_56_704 VGND VGND VPWR VPWR sky130_fd_sc_hd__decap_3
XFILLER_110_672 VGND VGND VPWR VPWR sky130_fd_sc_hd__decap_3
XFILLER_55_214 VGND VGND VPWR VPWR sky130_fd_sc_hd__fill_2
XFILLER_55_225 VGND VGND VPWR VPWR sky130_fd_sc_hd__decap_3
X_4086_ _7270_/Q _4437_/A2 _3935_/S _7334_/Q _4085_/X VGND VGND VPWR VPWR _4086_/X
+ sky130_fd_sc_hd__a221o_2
XFILLER_83_545 VGND VGND VPWR VPWR sky130_fd_sc_hd__fill_1
XFILLER_83_567 VGND VGND VPWR VPWR sky130_fd_sc_hd__decap_3
XFILLER_71_718 VGND VGND VPWR VPWR sky130_fd_sc_hd__decap_3
XFILLER_102_14 VGND VGND VPWR VPWR sky130_fd_sc_hd__fill_2
XTAP_TAPCELL_ROW_26_607 VGND VPWR sky130_fd_sc_hd__tapvpwrvgnd_1
XFILLER_71_729 VGND VGND VPWR VPWR sky130_fd_sc_hd__decap_3
XFILLER_36_461 VGND VGND VPWR VPWR sky130_fd_sc_hd__decap_3
XFILLER_24_601 VGND VGND VPWR VPWR sky130_fd_sc_hd__decap_3
XFILLER_36_483 VGND VGND VPWR VPWR sky130_fd_sc_hd__decap_3
XFILLER_24_634 VGND VGND VPWR VPWR sky130_fd_sc_hd__decap_3
XFILLER_51_420 VGND VGND VPWR VPWR sky130_fd_sc_hd__decap_3
XFILLER_24_645 VGND VGND VPWR VPWR sky130_fd_sc_hd__decap_3
XFILLER_51_442 VGND VGND VPWR VPWR sky130_fd_sc_hd__decap_3
Xplace280 _3871_/B1 VGND VGND VPWR VPWR _3883_/B1 sky130_fd_sc_hd__buf_2
XFILLER_24_678 VGND VGND VPWR VPWR sky130_fd_sc_hd__decap_3
Xplace291 _3890_/B1 VGND VGND VPWR VPWR _5660_/B sky130_fd_sc_hd__buf_2
XFILLER_23_155 VGND VGND VPWR VPWR sky130_fd_sc_hd__decap_3
X_4988_ _4988_/A _4988_/B VGND VGND VPWR VPWR _5004_/A sky130_fd_sc_hd__nor2_2
XFILLER_23_188 VGND VGND VPWR VPWR sky130_fd_sc_hd__fill_2
X_6727_ _7380_/CLK _6727_/D VGND VGND VPWR VPWR _6727_/Q sky130_fd_sc_hd__dfxtp_2
X_3939_ _7370_/Q _4482_/A0 _3943_/S VGND VGND VPWR VPWR _7370_/D sky130_fd_sc_hd__mux2_2
XFILLER_109_205 VGND VGND VPWR VPWR sky130_fd_sc_hd__fill_2
XPHY_EDGE_ROW_12_Left_136 VGND VGND VPWR VPWR sky130_fd_sc_hd__decap_3
X_6658_ _6658_/A VGND VGND VPWR VPWR _6658_/Y sky130_fd_sc_hd__inv_2
X_5609_ _5609_/A _5633_/B VGND VGND VPWR VPWR _7023_/D sky130_fd_sc_hd__or2_2
X_6589_ _6622_/A VGND VGND VPWR VPWR _6589_/Y sky130_fd_sc_hd__inv_2
XFILLER_3_505 VGND VGND VPWR VPWR sky130_fd_sc_hd__decap_3
XFILLER_11_55 VGND VGND VPWR VPWR sky130_fd_sc_hd__fill_1
XFILLER_3_538 VGND VGND VPWR VPWR sky130_fd_sc_hd__decap_3
XFILLER_11_88 VGND VGND VPWR VPWR sky130_fd_sc_hd__decap_3
XTAP_TAPCELL_ROW_111_1709 VGND VPWR sky130_fd_sc_hd__tapvpwrvgnd_1
XFILLER_87_15 VGND VGND VPWR VPWR sky130_fd_sc_hd__decap_3
XFILLER_2_6 VGND VGND VPWR VPWR sky130_fd_sc_hd__decap_3
XFILLER_105_466 VGND VGND VPWR VPWR sky130_fd_sc_hd__decap_3
XTAP_TAPCELL_ROW_6_343 VGND VPWR sky130_fd_sc_hd__tapvpwrvgnd_1
XFILLER_93_309 VGND VGND VPWR VPWR sky130_fd_sc_hd__decap_3
XFILLER_120_469 VGND VGND VPWR VPWR sky130_fd_sc_hd__decap_3
XFILLER_101_650 VGND VGND VPWR VPWR sky130_fd_sc_hd__decap_3
XPHY_EDGE_ROW_21_Left_145 VGND VGND VPWR VPWR sky130_fd_sc_hd__decap_3
XTAP_TAPCELL_ROW_70_1174 VGND VPWR sky130_fd_sc_hd__tapvpwrvgnd_1
XFILLER_86_361 VGND VGND VPWR VPWR sky130_fd_sc_hd__decap_3
XFILLER_47_715 VGND VGND VPWR VPWR sky130_fd_sc_hd__decap_3
XFILLER_19_417 VGND VGND VPWR VPWR sky130_fd_sc_hd__decap_3
XFILLER_101_694 VGND VGND VPWR VPWR sky130_fd_sc_hd__decap_3
XFILLER_46_225 VGND VGND VPWR VPWR sky130_fd_sc_hd__decap_3
XFILLER_100_171 VGND VGND VPWR VPWR sky130_fd_sc_hd__decap_3
XFILLER_62_707 VGND VGND VPWR VPWR sky130_fd_sc_hd__decap_3
XFILLER_74_589 VGND VGND VPWR VPWR sky130_fd_sc_hd__decap_3
XFILLER_61_206 VGND VGND VPWR VPWR sky130_fd_sc_hd__decap_3
XFILLER_15_612 VGND VGND VPWR VPWR sky130_fd_sc_hd__decap_3
XFILLER_61_228 VGND VGND VPWR VPWR sky130_fd_sc_hd__decap_3
XFILLER_15_623 VGND VGND VPWR VPWR sky130_fd_sc_hd__decap_3
XFILLER_36_85 VGND VGND VPWR VPWR sky130_fd_sc_hd__decap_3
XFILLER_14_100 VGND VGND VPWR VPWR sky130_fd_sc_hd__decap_3
XFILLER_27_494 VGND VGND VPWR VPWR sky130_fd_sc_hd__fill_1
XFILLER_14_111 VGND VGND VPWR VPWR sky130_fd_sc_hd__fill_2
XTAP_TAPCELL_ROW_122_1849 VGND VPWR sky130_fd_sc_hd__tapvpwrvgnd_1
XFILLER_15_656 VGND VGND VPWR VPWR sky130_fd_sc_hd__decap_3
XTAP_TAPCELL_ROW_53_960 VGND VPWR sky130_fd_sc_hd__tapvpwrvgnd_1
XFILLER_30_604 VGND VGND VPWR VPWR sky130_fd_sc_hd__decap_3
XFILLER_42_475 VGND VGND VPWR VPWR sky130_fd_sc_hd__fill_1
XFILLER_30_637 VGND VGND VPWR VPWR sky130_fd_sc_hd__decap_3
XFILLER_30_648 VGND VGND VPWR VPWR sky130_fd_sc_hd__decap_3
XPHY_EDGE_ROW_30_Left_154 VGND VGND VPWR VPWR sky130_fd_sc_hd__decap_3
XFILLER_6_365 VGND VGND VPWR VPWR sky130_fd_sc_hd__decap_3
XFILLER_97_615 VGND VGND VPWR VPWR sky130_fd_sc_hd__fill_1
XFILLER_69_306 VGND VGND VPWR VPWR sky130_fd_sc_hd__decap_3
XFILLER_97_626 VGND VGND VPWR VPWR sky130_fd_sc_hd__decap_3
XFILLER_2_560 VGND VGND VPWR VPWR sky130_fd_sc_hd__decap_3
XFILLER_97_659 VGND VGND VPWR VPWR sky130_fd_sc_hd__decap_3
XFILLER_123_296 VGND VGND VPWR VPWR sky130_fd_sc_hd__decap_3
XFILLER_96_147 VGND VGND VPWR VPWR sky130_fd_sc_hd__decap_3
XFILLER_84_309 VGND VGND VPWR VPWR sky130_fd_sc_hd__decap_3
XFILLER_38_704 VGND VGND VPWR VPWR sky130_fd_sc_hd__decap_3
XTAP_TAPCELL_ROW_88_1413 VGND VPWR sky130_fd_sc_hd__tapvpwrvgnd_1
XFILLER_65_523 VGND VGND VPWR VPWR sky130_fd_sc_hd__decap_3
XFILLER_37_225 VGND VGND VPWR VPWR sky130_fd_sc_hd__decap_3
XFILLER_92_331 VGND VGND VPWR VPWR sky130_fd_sc_hd__decap_3
XFILLER_65_545 VGND VGND VPWR VPWR sky130_fd_sc_hd__decap_3
XFILLER_37_258 VGND VGND VPWR VPWR sky130_fd_sc_hd__fill_2
XFILLER_53_718 VGND VGND VPWR VPWR sky130_fd_sc_hd__decap_3
XFILLER_65_589 VGND VGND VPWR VPWR sky130_fd_sc_hd__decap_3
XFILLER_53_729 VGND VGND VPWR VPWR sky130_fd_sc_hd__decap_3
XFILLER_18_472 VGND VGND VPWR VPWR sky130_fd_sc_hd__decap_3
XFILLER_18_483 VGND VGND VPWR VPWR sky130_fd_sc_hd__fill_2
X_4911_ _6997_/Q _4931_/A VGND VGND VPWR VPWR _4912_/B sky130_fd_sc_hd__nor2_2
XFILLER_33_420 VGND VGND VPWR VPWR sky130_fd_sc_hd__fill_1
XFILLER_21_604 VGND VGND VPWR VPWR sky130_fd_sc_hd__decap_3
X_4842_ _4643_/Y _4841_/Y _4845_/A VGND VGND VPWR VPWR _4842_/X sky130_fd_sc_hd__a21o_2
XFILLER_60_250 VGND VGND VPWR VPWR sky130_fd_sc_hd__fill_2
XFILLER_21_626 VGND VGND VPWR VPWR sky130_fd_sc_hd__decap_3
XFILLER_21_659 VGND VGND VPWR VPWR sky130_fd_sc_hd__decap_3
XFILLER_20_147 VGND VGND VPWR VPWR sky130_fd_sc_hd__decap_3
XFILLER_119_514 VGND VGND VPWR VPWR sky130_fd_sc_hd__decap_3
XTAP_TAPCELL_ROW_31_665 VGND VPWR sky130_fd_sc_hd__tapvpwrvgnd_1
X_3724_ _6828_/Q _3888_/A2 _3891_/A2 _6818_/Q _3723_/X VGND VGND VPWR VPWR _3724_/X
+ sky130_fd_sc_hd__a221o_2
X_6512_ _6644_/A VGND VGND VPWR VPWR _6512_/Y sky130_fd_sc_hd__inv_2
XTAP_TAPCELL_ROW_31_676 VGND VPWR sky130_fd_sc_hd__tapvpwrvgnd_1
XTAP_TAPCELL_ROW_99_1553 VGND VPWR sky130_fd_sc_hd__tapvpwrvgnd_1
XFILLER_119_547 VGND VGND VPWR VPWR sky130_fd_sc_hd__decap_3
XFILLER_107_709 VGND VGND VPWR VPWR sky130_fd_sc_hd__decap_3
X_6443_ _6602_/A VGND VGND VPWR VPWR _6443_/Y sky130_fd_sc_hd__inv_2
X_6374_ _6602_/A VGND VGND VPWR VPWR _6374_/Y sky130_fd_sc_hd__inv_2
X_3586_ _3591_/A _3591_/B _3591_/C _3586_/D VGND VGND VPWR VPWR _3586_/Y sky130_fd_sc_hd__nor4_2
X_5325_ _5325_/A0 _4964_/X _5340_/S VGND VGND VPWR VPWR _7168_/D sky130_fd_sc_hd__mux2_2
XFILLER_114_230 VGND VGND VPWR VPWR sky130_fd_sc_hd__fill_2
XFILLER_88_604 VGND VGND VPWR VPWR sky130_fd_sc_hd__decap_3
XFILLER_0_519 VGND VGND VPWR VPWR sky130_fd_sc_hd__decap_3
XFILLER_88_637 VGND VGND VPWR VPWR sky130_fd_sc_hd__decap_3
XFILLER_87_103 VGND VGND VPWR VPWR sky130_fd_sc_hd__decap_3
X_5256_ _5256_/A0 _4932_/X _5258_/S VGND VGND VPWR VPWR _7202_/D sky130_fd_sc_hd__mux2_2
XFILLER_88_648 VGND VGND VPWR VPWR sky130_fd_sc_hd__decap_3
XFILLER_87_125 VGND VGND VPWR VPWR sky130_fd_sc_hd__decap_3
XFILLER_102_458 VGND VGND VPWR VPWR sky130_fd_sc_hd__decap_3
X_4207_ _4207_/A _4642_/B VGND VGND VPWR VPWR _4208_/B sky130_fd_sc_hd__and2_2
XFILLER_87_158 VGND VGND VPWR VPWR sky130_fd_sc_hd__decap_3
XTAP_TAPCELL_ROW_3_302 VGND VPWR sky130_fd_sc_hd__tapvpwrvgnd_1
XFILLER_29_715 VGND VGND VPWR VPWR sky130_fd_sc_hd__decap_3
XFILLER_96_681 VGND VGND VPWR VPWR sky130_fd_sc_hd__decap_3
XFILLER_28_203 VGND VGND VPWR VPWR sky130_fd_sc_hd__decap_3
X_4138_ _4134_/X _4137_/X _4425_/A VGND VGND VPWR VPWR _4642_/B sky130_fd_sc_hd__o21a_2
XFILLER_28_236 VGND VGND VPWR VPWR sky130_fd_sc_hd__decap_3
XFILLER_113_24 VGND VGND VPWR VPWR sky130_fd_sc_hd__decap_3
XFILLER_110_491 VGND VGND VPWR VPWR sky130_fd_sc_hd__decap_3
XFILLER_95_191 VGND VGND VPWR VPWR sky130_fd_sc_hd__decap_3
XFILLER_44_707 VGND VGND VPWR VPWR sky130_fd_sc_hd__decap_3
XFILLER_113_57 VGND VGND VPWR VPWR sky130_fd_sc_hd__decap_3
XTAP_TAPCELL_ROW_39_776 VGND VPWR sky130_fd_sc_hd__tapvpwrvgnd_1
X_4069_ _4744_/B _4069_/B VGND VGND VPWR VPWR _4069_/Y sky130_fd_sc_hd__nor2_2
XFILLER_56_589 VGND VGND VPWR VPWR sky130_fd_sc_hd__fill_1
XTAP_TAPCELL_ROW_108_1671 VGND VPWR sky130_fd_sc_hd__tapvpwrvgnd_1
XFILLER_43_228 VGND VGND VPWR VPWR sky130_fd_sc_hd__decap_3
XFILLER_71_548 VGND VGND VPWR VPWR sky130_fd_sc_hd__decap_3
XFILLER_36_280 VGND VGND VPWR VPWR sky130_fd_sc_hd__decap_3
XFILLER_12_604 VGND VGND VPWR VPWR sky130_fd_sc_hd__decap_3
XFILLER_24_486 VGND VGND VPWR VPWR sky130_fd_sc_hd__decap_3
XFILLER_11_103 VGND VGND VPWR VPWR sky130_fd_sc_hd__decap_3
XFILLER_12_637 VGND VGND VPWR VPWR sky130_fd_sc_hd__decap_3
XFILLER_12_648 VGND VGND VPWR VPWR sky130_fd_sc_hd__decap_3
XFILLER_8_619 VGND VGND VPWR VPWR sky130_fd_sc_hd__decap_3
XFILLER_11_169 VGND VGND VPWR VPWR sky130_fd_sc_hd__decap_3
XFILLER_22_32 VGND VGND VPWR VPWR sky130_fd_sc_hd__fill_2
XFILLER_22_54 VGND VGND VPWR VPWR sky130_fd_sc_hd__decap_3
XFILLER_20_681 VGND VGND VPWR VPWR sky130_fd_sc_hd__decap_3
XTAP_TAPCELL_ROW_59_1036 VGND VPWR sky130_fd_sc_hd__tapvpwrvgnd_1
XFILLER_118_3 VGND VGND VPWR VPWR sky130_fd_sc_hd__decap_3
XFILLER_106_731 VGND VGND VPWR VPWR sky130_fd_sc_hd__decap_3
XFILLER_3_335 VGND VGND VPWR VPWR sky130_fd_sc_hd__fill_1
XTAP_TAPCELL_ROW_72_1203 VGND VPWR sky130_fd_sc_hd__tapvpwrvgnd_1
XFILLER_79_615 VGND VGND VPWR VPWR sky130_fd_sc_hd__fill_1
XFILLER_3_379 VGND VGND VPWR VPWR sky130_fd_sc_hd__decap_3
XFILLER_121_712 VGND VGND VPWR VPWR sky130_fd_sc_hd__decap_3
XFILLER_79_626 VGND VGND VPWR VPWR sky130_fd_sc_hd__decap_3
XFILLER_78_103 VGND VGND VPWR VPWR sky130_fd_sc_hd__decap_3
XFILLER_105_263 VGND VGND VPWR VPWR sky130_fd_sc_hd__decap_3
XFILLER_79_659 VGND VGND VPWR VPWR sky130_fd_sc_hd__decap_3
XFILLER_78_136 VGND VGND VPWR VPWR sky130_fd_sc_hd__decap_3
XFILLER_78_147 VGND VGND VPWR VPWR sky130_fd_sc_hd__decap_3
XFILLER_94_607 VGND VGND VPWR VPWR sky130_fd_sc_hd__decap_3
XFILLER_66_309 VGND VGND VPWR VPWR sky130_fd_sc_hd__decap_3
XFILLER_19_203 VGND VGND VPWR VPWR sky130_fd_sc_hd__decap_3
XFILLER_59_383 VGND VGND VPWR VPWR sky130_fd_sc_hd__fill_2
XFILLER_120_288 VGND VGND VPWR VPWR sky130_fd_sc_hd__fill_1
XFILLER_120_299 VGND VGND VPWR VPWR sky130_fd_sc_hd__decap_3
XFILLER_19_225 VGND VGND VPWR VPWR sky130_fd_sc_hd__decap_3
XFILLER_101_491 VGND VGND VPWR VPWR sky130_fd_sc_hd__fill_2
XFILLER_47_567 VGND VGND VPWR VPWR sky130_fd_sc_hd__fill_1
XFILLER_35_718 VGND VGND VPWR VPWR sky130_fd_sc_hd__decap_3
XFILLER_19_269 VGND VGND VPWR VPWR sky130_fd_sc_hd__decap_3
XFILLER_62_504 VGND VGND VPWR VPWR sky130_fd_sc_hd__fill_2
XFILLER_35_729 VGND VGND VPWR VPWR sky130_fd_sc_hd__decap_3
XFILLER_34_228 VGND VGND VPWR VPWR sky130_fd_sc_hd__decap_3
XTAP_TAPCELL_ROW_83_1343 VGND VPWR sky130_fd_sc_hd__tapvpwrvgnd_1
XFILLER_30_412 VGND VGND VPWR VPWR sky130_fd_sc_hd__decap_3
XFILLER_70_581 VGND VGND VPWR VPWR sky130_fd_sc_hd__decap_3
XFILLER_42_272 VGND VGND VPWR VPWR sky130_fd_sc_hd__decap_3
XFILLER_70_592 VGND VGND VPWR VPWR sky130_fd_sc_hd__decap_3
XFILLER_42_294 VGND VGND VPWR VPWR sky130_fd_sc_hd__fill_1
XFILLER_7_641 VGND VGND VPWR VPWR sky130_fd_sc_hd__decap_3
XFILLER_116_506 VGND VGND VPWR VPWR sky130_fd_sc_hd__decap_3
Xwire572 _6569_/A VGND VGND VPWR VPWR _6570_/A sky130_fd_sc_hd__buf_2
Xhold608 _6960_/Q VGND VGND VPWR VPWR _6960_/D sky130_fd_sc_hd__dlygate4sd3_1
XFILLER_7_685 VGND VGND VPWR VPWR sky130_fd_sc_hd__decap_3
X_3440_ _7250_/Q _4601_/S _3434_/X _3439_/X VGND VGND VPWR VPWR _3440_/X sky130_fd_sc_hd__a211o_2
Xhold619 _6834_/Q VGND VGND VPWR VPWR _6834_/D sky130_fd_sc_hd__dlygate4sd3_1
XFILLER_116_539 VGND VGND VPWR VPWR sky130_fd_sc_hd__decap_3
XFILLER_6_173 VGND VGND VPWR VPWR sky130_fd_sc_hd__decap_3
XFILLER_109_591 VGND VGND VPWR VPWR sky130_fd_sc_hd__decap_3
X_3371_ _3371_/A _5118_/D _5118_/A _5129_/B VGND VGND VPWR VPWR _3371_/Y sky130_fd_sc_hd__nor4bb_2
XFILLER_112_701 VGND VGND VPWR VPWR sky130_fd_sc_hd__decap_3
XTAP_TAPCELL_ROW_94_1483 VGND VPWR sky130_fd_sc_hd__tapvpwrvgnd_1
XTAP_TAPCELL_ROW_94_1494 VGND VPWR sky130_fd_sc_hd__tapvpwrvgnd_1
X_5110_ _3610_/A _3603_/Y _4292_/C VGND VGND VPWR VPWR _5110_/Y sky130_fd_sc_hd__a21oi_2
XFILLER_88_80 VGND VGND VPWR VPWR sky130_fd_sc_hd__decap_3
XFILLER_112_734 VGND VGND VPWR VPWR sky130_fd_sc_hd__fill_1
XFILLER_97_434 VGND VGND VPWR VPWR sky130_fd_sc_hd__decap_3
XFILLER_88_91 VGND VGND VPWR VPWR sky130_fd_sc_hd__decap_3
XFILLER_33_3 VGND VGND VPWR VPWR sky130_fd_sc_hd__decap_3
XFILLER_69_158 VGND VGND VPWR VPWR sky130_fd_sc_hd__decap_3
XFILLER_111_244 VGND VGND VPWR VPWR sky130_fd_sc_hd__decap_3
X_5041_ _5041_/A0 _5040_/X _5080_/S VGND VGND VPWR VPWR _7259_/D sky130_fd_sc_hd__mux2_2
XFILLER_57_309 VGND VGND VPWR VPWR sky130_fd_sc_hd__fill_1
XFILLER_69_169 VGND VGND VPWR VPWR sky130_fd_sc_hd__decap_3
XFILLER_97_489 VGND VGND VPWR VPWR sky130_fd_sc_hd__fill_2
XFILLER_85_629 VGND VGND VPWR VPWR sky130_fd_sc_hd__decap_3
XFILLER_111_277 VGND VGND VPWR VPWR sky130_fd_sc_hd__decap_3
XFILLER_84_128 VGND VGND VPWR VPWR sky130_fd_sc_hd__decap_3
XFILLER_78_681 VGND VGND VPWR VPWR sky130_fd_sc_hd__decap_3
XFILLER_111_299 VGND VGND VPWR VPWR sky130_fd_sc_hd__decap_3
XFILLER_65_320 VGND VGND VPWR VPWR sky130_fd_sc_hd__decap_3
XFILLER_26_707 VGND VGND VPWR VPWR sky130_fd_sc_hd__decap_3
XFILLER_93_662 VGND VGND VPWR VPWR sky130_fd_sc_hd__decap_3
XFILLER_93_673 VGND VGND VPWR VPWR sky130_fd_sc_hd__decap_3
XFILLER_80_301 VGND VGND VPWR VPWR sky130_fd_sc_hd__decap_3
XFILLER_38_589 VGND VGND VPWR VPWR sky130_fd_sc_hd__decap_3
X_6992_ _7398_/CLK _6992_/D _6272_/Y VGND VGND VPWR VPWR _6992_/Q sky130_fd_sc_hd__dfrtp_2
XFILLER_65_386 VGND VGND VPWR VPWR sky130_fd_sc_hd__fill_2
XFILLER_80_312 VGND VGND VPWR VPWR sky130_fd_sc_hd__decap_3
XFILLER_92_183 VGND VGND VPWR VPWR sky130_fd_sc_hd__decap_3
XTAP_TAPCELL_ROW_36_735 VGND VPWR sky130_fd_sc_hd__tapvpwrvgnd_1
XFILLER_25_239 VGND VGND VPWR VPWR sky130_fd_sc_hd__decap_3
XTAP_TAPCELL_ROW_16_470 VGND VPWR sky130_fd_sc_hd__tapvpwrvgnd_1
XFILLER_61_592 VGND VGND VPWR VPWR sky130_fd_sc_hd__decap_3
XTAP_TAPCELL_ROW_16_481 VGND VPWR sky130_fd_sc_hd__tapvpwrvgnd_1
X_4825_ _7001_/Q _4825_/B VGND VGND VPWR VPWR _4826_/B sky130_fd_sc_hd__nor2_2
XFILLER_119_300 VGND VGND VPWR VPWR sky130_fd_sc_hd__decap_3
XFILLER_21_478 VGND VGND VPWR VPWR sky130_fd_sc_hd__decap_3
XFILLER_119_355 VGND VGND VPWR VPWR sky130_fd_sc_hd__fill_2
X_3707_ _6937_/Q _3898_/A2 _3759_/B1 _6889_/Q VGND VGND VPWR VPWR _3707_/X sky130_fd_sc_hd__a22o_2
X_4687_ _7001_/Q _4687_/B VGND VGND VPWR VPWR _4834_/A sky130_fd_sc_hd__and2_2
XFILLER_107_517 VGND VGND VPWR VPWR sky130_fd_sc_hd__decap_3
XFILLER_119_399 VGND VGND VPWR VPWR sky130_fd_sc_hd__decap_3
X_3638_ _3635_/A _3521_/Y _3547_/A VGND VGND VPWR VPWR _3638_/X sky130_fd_sc_hd__a21bo_2
X_6426_ _6649_/A VGND VGND VPWR VPWR _6426_/Y sky130_fd_sc_hd__inv_2
XFILLER_108_35 VGND VGND VPWR VPWR sky130_fd_sc_hd__decap_3
XFILLER_115_550 VGND VGND VPWR VPWR sky130_fd_sc_hd__decap_3
X_3569_ _7285_/Q _5140_/S _3567_/X _3568_/X VGND VGND VPWR VPWR _3569_/X sky130_fd_sc_hd__a211o_2
X_6357_ _6363_/A VGND VGND VPWR VPWR _6357_/Y sky130_fd_sc_hd__inv_2
XFILLER_88_401 VGND VGND VPWR VPWR sky130_fd_sc_hd__decap_3
XFILLER_68_17 VGND VGND VPWR VPWR sky130_fd_sc_hd__decap_3
XFILLER_115_561 VGND VGND VPWR VPWR sky130_fd_sc_hd__decap_3
XFILLER_0_305 VGND VGND VPWR VPWR sky130_fd_sc_hd__decap_3
XFILLER_103_712 VGND VGND VPWR VPWR sky130_fd_sc_hd__decap_3
X_5308_ _5308_/A0 _4822_/X _5315_/S VGND VGND VPWR VPWR _7176_/D sky130_fd_sc_hd__mux2_2
XFILLER_115_594 VGND VGND VPWR VPWR sky130_fd_sc_hd__decap_3
X_6288_ _6288_/A VGND VGND VPWR VPWR _6288_/Y sky130_fd_sc_hd__inv_2
XFILLER_76_607 VGND VGND VPWR VPWR sky130_fd_sc_hd__decap_3
XFILLER_102_244 VGND VGND VPWR VPWR sky130_fd_sc_hd__decap_3
X_5239_ hold972/X _5238_/X _4766_/A VGND VGND VPWR VPWR _7211_/D sky130_fd_sc_hd__a21o_2
XFILLER_29_501 VGND VGND VPWR VPWR sky130_fd_sc_hd__decap_3
XFILLER_75_128 VGND VGND VPWR VPWR sky130_fd_sc_hd__decap_3
XFILLER_29_534 VGND VGND VPWR VPWR sky130_fd_sc_hd__decap_3
XFILLER_84_640 VGND VGND VPWR VPWR sky130_fd_sc_hd__decap_3
XFILLER_84_651 VGND VGND VPWR VPWR sky130_fd_sc_hd__decap_3
XFILLER_17_718 VGND VGND VPWR VPWR sky130_fd_sc_hd__decap_3
XFILLER_83_150 VGND VGND VPWR VPWR sky130_fd_sc_hd__decap_3
XFILLER_29_589 VGND VGND VPWR VPWR sky130_fd_sc_hd__decap_3
XFILLER_17_729 VGND VGND VPWR VPWR sky130_fd_sc_hd__decap_3
XFILLER_84_684 VGND VGND VPWR VPWR sky130_fd_sc_hd__decap_3
XFILLER_56_386 VGND VGND VPWR VPWR sky130_fd_sc_hd__fill_1
XFILLER_71_323 VGND VGND VPWR VPWR sky130_fd_sc_hd__decap_3
XFILLER_17_54 VGND VGND VPWR VPWR sky130_fd_sc_hd__fill_2
XFILLER_44_559 VGND VGND VPWR VPWR sky130_fd_sc_hd__decap_3
XFILLER_71_356 VGND VGND VPWR VPWR sky130_fd_sc_hd__fill_2
XFILLER_71_378 VGND VGND VPWR VPWR sky130_fd_sc_hd__decap_3
XFILLER_40_710 VGND VGND VPWR VPWR sky130_fd_sc_hd__decap_3
XFILLER_12_401 VGND VGND VPWR VPWR sky130_fd_sc_hd__decap_3
XFILLER_24_283 VGND VGND VPWR VPWR sky130_fd_sc_hd__decap_3
XFILLER_8_427 VGND VGND VPWR VPWR sky130_fd_sc_hd__decap_3
XFILLER_4_622 VGND VGND VPWR VPWR sky130_fd_sc_hd__decap_3
XFILLER_4_666 VGND VGND VPWR VPWR sky130_fd_sc_hd__decap_3
XFILLER_3_154 VGND VGND VPWR VPWR sky130_fd_sc_hd__decap_3
XFILLER_106_572 VGND VGND VPWR VPWR sky130_fd_sc_hd__decap_3
XFILLER_3_165 VGND VGND VPWR VPWR sky130_fd_sc_hd__decap_3
XFILLER_79_423 VGND VGND VPWR VPWR sky130_fd_sc_hd__decap_3
XFILLER_4_699 VGND VGND VPWR VPWR sky130_fd_sc_hd__fill_1
XFILLER_3_187 VGND VGND VPWR VPWR sky130_fd_sc_hd__decap_3
XFILLER_121_520 VGND VGND VPWR VPWR sky130_fd_sc_hd__decap_3
XFILLER_79_445 VGND VGND VPWR VPWR sky130_fd_sc_hd__decap_3
XFILLER_121_553 VGND VGND VPWR VPWR sky130_fd_sc_hd__decap_3
XFILLER_121_564 VGND VGND VPWR VPWR sky130_fd_sc_hd__decap_3
XFILLER_67_629 VGND VGND VPWR VPWR sky130_fd_sc_hd__decap_3
XFILLER_58_83 VGND VGND VPWR VPWR sky130_fd_sc_hd__fill_1
XFILLER_121_597 VGND VGND VPWR VPWR sky130_fd_sc_hd__decap_3
XFILLER_94_448 VGND VGND VPWR VPWR sky130_fd_sc_hd__fill_1
XFILLER_47_331 VGND VGND VPWR VPWR sky130_fd_sc_hd__decap_3
XFILLER_75_662 VGND VGND VPWR VPWR sky130_fd_sc_hd__decap_3
XFILLER_75_673 VGND VGND VPWR VPWR sky130_fd_sc_hd__decap_3
XFILLER_74_150 VGND VGND VPWR VPWR sky130_fd_sc_hd__decap_3
XFILLER_90_610 VGND VGND VPWR VPWR sky130_fd_sc_hd__decap_3
XFILLER_62_301 VGND VGND VPWR VPWR sky130_fd_sc_hd__decap_3
XFILLER_62_312 VGND VGND VPWR VPWR sky130_fd_sc_hd__decap_3
XFILLER_47_386 VGND VGND VPWR VPWR sky130_fd_sc_hd__decap_3
XFILLER_74_183 VGND VGND VPWR VPWR sky130_fd_sc_hd__fill_1
XFILLER_90_643 VGND VGND VPWR VPWR sky130_fd_sc_hd__fill_1
XFILLER_74_71 VGND VGND VPWR VPWR sky130_fd_sc_hd__fill_2
XFILLER_74_194 VGND VGND VPWR VPWR sky130_fd_sc_hd__fill_2
XFILLER_90_654 VGND VGND VPWR VPWR sky130_fd_sc_hd__decap_3
XFILLER_74_82 VGND VGND VPWR VPWR sky130_fd_sc_hd__fill_2
XFILLER_74_93 VGND VGND VPWR VPWR sky130_fd_sc_hd__decap_3
XFILLER_50_507 VGND VGND VPWR VPWR sky130_fd_sc_hd__decap_3
XFILLER_90_687 VGND VGND VPWR VPWR sky130_fd_sc_hd__decap_3
XFILLER_31_721 VGND VGND VPWR VPWR sky130_fd_sc_hd__decap_3
XFILLER_31_732 VGND VGND VPWR VPWR sky130_fd_sc_hd__decap_3
XTAP_TAPCELL_ROW_13_440 VGND VPWR sky130_fd_sc_hd__tapvpwrvgnd_1
X_4610_ _4745_/A _4762_/B VGND VGND VPWR VPWR _4611_/A sky130_fd_sc_hd__nand2_2
XFILLER_30_297 VGND VGND VPWR VPWR sky130_fd_sc_hd__fill_2
XTAP_TAPCELL_ROW_96_1512 VGND VPWR sky130_fd_sc_hd__tapvpwrvgnd_1
X_7260_ _7360_/CLK _7260_/D _6540_/Y VGND VGND VPWR VPWR _7260_/Q sky130_fd_sc_hd__dfrtp_2
XFILLER_116_358 VGND VGND VPWR VPWR sky130_fd_sc_hd__decap_3
X_3423_ _3442_/A _3442_/B _5688_/S VGND VGND VPWR VPWR _3424_/S sky130_fd_sc_hd__and3_4
X_7191_ _7325_/CLK _7191_/D _6471_/Y VGND VGND VPWR VPWR _7191_/Q sky130_fd_sc_hd__dfrtp_2
XFILLER_98_710 VGND VGND VPWR VPWR sky130_fd_sc_hd__decap_3
X_3354_ _3371_/A _5668_/A _3328_/B _3561_/B VGND VGND VPWR VPWR _3354_/X sky130_fd_sc_hd__a211o_2
XFILLER_112_531 VGND VGND VPWR VPWR sky130_fd_sc_hd__fill_1
XFILLER_112_542 VGND VGND VPWR VPWR sky130_fd_sc_hd__decap_3
XFILLER_97_253 VGND VGND VPWR VPWR sky130_fd_sc_hd__decap_3
XFILLER_100_704 VGND VGND VPWR VPWR sky130_fd_sc_hd__decap_3
XFILLER_58_629 VGND VGND VPWR VPWR sky130_fd_sc_hd__decap_3
XFILLER_112_575 VGND VGND VPWR VPWR sky130_fd_sc_hd__decap_3
Xhold1105 _7132_/Q VGND VGND VPWR VPWR _5402_/A0 sky130_fd_sc_hd__dlygate4sd3_1
XFILLER_57_106 VGND VGND VPWR VPWR sky130_fd_sc_hd__decap_3
Xhold1116 _7120_/Q VGND VGND VPWR VPWR _5427_/A0 sky130_fd_sc_hd__dlygate4sd3_1
X_5024_ _3860_/S _3832_/X _5015_/X _5023_/Y VGND VGND VPWR VPWR _5024_/X sky130_fd_sc_hd__a211o_2
Xhold1127 _7235_/Q VGND VGND VPWR VPWR _5186_/A sky130_fd_sc_hd__dlygate4sd3_1
Xhold1138 _7221_/Q VGND VGND VPWR VPWR _5215_/A sky130_fd_sc_hd__dlygate4sd3_1
Xhold1149 _7338_/Q VGND VGND VPWR VPWR _4482_/A0 sky130_fd_sc_hd__dlygate4sd3_1
XFILLER_85_459 VGND VGND VPWR VPWR sky130_fd_sc_hd__decap_3
XFILLER_66_651 VGND VGND VPWR VPWR sky130_fd_sc_hd__decap_3
XFILLER_72_109 VGND VGND VPWR VPWR sky130_fd_sc_hd__decap_3
XFILLER_66_684 VGND VGND VPWR VPWR sky130_fd_sc_hd__decap_3
XFILLER_93_470 VGND VGND VPWR VPWR sky130_fd_sc_hd__decap_3
XFILLER_93_492 VGND VGND VPWR VPWR sky130_fd_sc_hd__decap_3
XFILLER_81_632 VGND VGND VPWR VPWR sky130_fd_sc_hd__decap_3
XFILLER_53_323 VGND VGND VPWR VPWR sky130_fd_sc_hd__fill_2
XFILLER_53_345 VGND VGND VPWR VPWR sky130_fd_sc_hd__decap_3
XTAP_TAPCELL_ROW_105_1630 VGND VPWR sky130_fd_sc_hd__tapvpwrvgnd_1
X_6975_ clkload6/A _6975_/D VGND VGND VPWR VPWR _6975_/Q sky130_fd_sc_hd__dfxtp_2
XFILLER_81_665 VGND VGND VPWR VPWR sky130_fd_sc_hd__decap_3
XFILLER_81_676 VGND VGND VPWR VPWR sky130_fd_sc_hd__decap_3
XFILLER_53_367 VGND VGND VPWR VPWR sky130_fd_sc_hd__decap_3
XFILLER_22_710 VGND VGND VPWR VPWR sky130_fd_sc_hd__decap_3
XFILLER_80_186 VGND VGND VPWR VPWR sky130_fd_sc_hd__decap_3
XFILLER_80_197 VGND VGND VPWR VPWR sky130_fd_sc_hd__decap_3
XFILLER_34_592 VGND VGND VPWR VPWR sky130_fd_sc_hd__decap_3
XFILLER_110_47 VGND VGND VPWR VPWR sky130_fd_sc_hd__decap_3
XFILLER_70_18 VGND VGND VPWR VPWR sky130_fd_sc_hd__decap_3
XFILLER_21_231 VGND VGND VPWR VPWR sky130_fd_sc_hd__decap_3
XFILLER_70_29 VGND VGND VPWR VPWR sky130_fd_sc_hd__decap_3
XFILLER_21_264 VGND VGND VPWR VPWR sky130_fd_sc_hd__decap_3
XFILLER_119_12 VGND VGND VPWR VPWR sky130_fd_sc_hd__decap_3
X_4739_ _4762_/A _4762_/B _4765_/B _4745_/A VGND VGND VPWR VPWR _4739_/Y sky130_fd_sc_hd__a211oi_2
XFILLER_119_45 VGND VGND VPWR VPWR sky130_fd_sc_hd__decap_3
XFILLER_119_185 VGND VGND VPWR VPWR sky130_fd_sc_hd__fill_1
XFILLER_79_27 VGND VGND VPWR VPWR sky130_fd_sc_hd__decap_3
XFILLER_119_78 VGND VGND VPWR VPWR sky130_fd_sc_hd__decap_3
XTAP_TAPCELL_ROW_116_1770 VGND VPWR sky130_fd_sc_hd__tapvpwrvgnd_1
X_6409_ _6638_/A VGND VGND VPWR VPWR _6409_/Y sky130_fd_sc_hd__inv_2
XTAP_TAPCELL_ROW_116_1781 VGND VPWR sky130_fd_sc_hd__tapvpwrvgnd_1
Xhold950 _7381_/Q VGND VGND VPWR VPWR hold950/X sky130_fd_sc_hd__dlygate4sd3_1
XFILLER_1_603 VGND VGND VPWR VPWR sky130_fd_sc_hd__decap_3
Xhold961 _7026_/Q VGND VGND VPWR VPWR _5602_/A sky130_fd_sc_hd__dlygate4sd3_1
X_7389_ _7392_/CLK _7389_/D _6669_/Y VGND VGND VPWR VPWR _7389_/Q sky130_fd_sc_hd__dfrtp_2
Xhold972 _7211_/Q VGND VGND VPWR VPWR hold972/X sky130_fd_sc_hd__dlygate4sd3_1
XFILLER_89_721 VGND VGND VPWR VPWR sky130_fd_sc_hd__decap_3
XFILLER_89_732 VGND VGND VPWR VPWR sky130_fd_sc_hd__decap_3
XFILLER_0_113 VGND VGND VPWR VPWR sky130_fd_sc_hd__decap_3
Xhold983 _7210_/Q VGND VGND VPWR VPWR hold983/X sky130_fd_sc_hd__dlygate4sd3_1
Xhold994 _7267_/Q VGND VGND VPWR VPWR hold994/X sky130_fd_sc_hd__dlygate4sd3_1
XFILLER_1_647 VGND VGND VPWR VPWR sky130_fd_sc_hd__decap_3
XFILLER_103_553 VGND VGND VPWR VPWR sky130_fd_sc_hd__decap_3
XFILLER_95_26 VGND VGND VPWR VPWR sky130_fd_sc_hd__decap_3
XFILLER_88_264 VGND VGND VPWR VPWR sky130_fd_sc_hd__fill_2
XFILLER_76_404 VGND VGND VPWR VPWR sky130_fd_sc_hd__decap_3
XFILLER_103_564 VGND VGND VPWR VPWR sky130_fd_sc_hd__decap_3
XFILLER_49_629 VGND VGND VPWR VPWR sky130_fd_sc_hd__decap_3
XFILLER_88_286 VGND VGND VPWR VPWR sky130_fd_sc_hd__fill_1
XFILLER_103_597 VGND VGND VPWR VPWR sky130_fd_sc_hd__decap_3
XFILLER_91_407 VGND VGND VPWR VPWR sky130_fd_sc_hd__decap_3
XFILLER_57_662 VGND VGND VPWR VPWR sky130_fd_sc_hd__decap_3
XFILLER_63_109 VGND VGND VPWR VPWR sky130_fd_sc_hd__decap_3
XFILLER_57_673 VGND VGND VPWR VPWR sky130_fd_sc_hd__decap_3
XFILLER_91_429 VGND VGND VPWR VPWR sky130_fd_sc_hd__decap_3
XFILLER_72_610 VGND VGND VPWR VPWR sky130_fd_sc_hd__decap_3
XFILLER_44_312 VGND VGND VPWR VPWR sky130_fd_sc_hd__decap_3
XTAP_TAPCELL_ROW_67_1135 VGND VPWR sky130_fd_sc_hd__tapvpwrvgnd_1
XFILLER_72_643 VGND VGND VPWR VPWR sky130_fd_sc_hd__fill_1
XFILLER_44_334 VGND VGND VPWR VPWR sky130_fd_sc_hd__decap_3
XFILLER_17_559 VGND VGND VPWR VPWR sky130_fd_sc_hd__fill_1
XFILLER_72_654 VGND VGND VPWR VPWR sky130_fd_sc_hd__decap_3
XFILLER_71_142 VGND VGND VPWR VPWR sky130_fd_sc_hd__decap_3
XFILLER_32_507 VGND VGND VPWR VPWR sky130_fd_sc_hd__decap_3
XFILLER_72_687 VGND VGND VPWR VPWR sky130_fd_sc_hd__decap_3
XTAP_TAPCELL_ROW_80_1302 VGND VPWR sky130_fd_sc_hd__tapvpwrvgnd_1
XFILLER_25_570 VGND VGND VPWR VPWR sky130_fd_sc_hd__decap_3
XTAP_TAPCELL_ROW_80_1313 VGND VPWR sky130_fd_sc_hd__tapvpwrvgnd_1
XFILLER_71_186 VGND VGND VPWR VPWR sky130_fd_sc_hd__decap_3
XFILLER_13_721 VGND VGND VPWR VPWR sky130_fd_sc_hd__decap_3
XFILLER_13_732 VGND VGND VPWR VPWR sky130_fd_sc_hd__decap_3
XFILLER_9_703 VGND VGND VPWR VPWR sky130_fd_sc_hd__decap_3
XPHY_EDGE_ROW_4_Left_128 VGND VGND VPWR VPWR sky130_fd_sc_hd__decap_3
XFILLER_12_231 VGND VGND VPWR VPWR sky130_fd_sc_hd__decap_3
XFILLER_12_253 VGND VGND VPWR VPWR sky130_fd_sc_hd__decap_3
XFILLER_40_562 VGND VGND VPWR VPWR sky130_fd_sc_hd__decap_3
XFILLER_8_213 VGND VGND VPWR VPWR sky130_fd_sc_hd__decap_3
XFILLER_8_235 VGND VGND VPWR VPWR sky130_fd_sc_hd__decap_3
XFILLER_40_595 VGND VGND VPWR VPWR sky130_fd_sc_hd__decap_3
XFILLER_100_91 VGND VGND VPWR VPWR sky130_fd_sc_hd__decap_3
XFILLER_67_9 VGND VGND VPWR VPWR sky130_fd_sc_hd__decap_3
XTAP_TAPCELL_ROW_78_1275 VGND VPWR sky130_fd_sc_hd__tapvpwrvgnd_1
XTAP_TAPCELL_ROW_78_1286 VGND VPWR sky130_fd_sc_hd__tapvpwrvgnd_1
XFILLER_5_46 VGND VGND VPWR VPWR sky130_fd_sc_hd__decap_3
XTAP_TAPCELL_ROW_91_1453 VGND VPWR sky130_fd_sc_hd__tapvpwrvgnd_1
XFILLER_79_253 VGND VGND VPWR VPWR sky130_fd_sc_hd__decap_3
XFILLER_95_724 VGND VGND VPWR VPWR sky130_fd_sc_hd__decap_3
XFILLER_94_212 VGND VGND VPWR VPWR sky130_fd_sc_hd__decap_3
XFILLER_67_426 VGND VGND VPWR VPWR sky130_fd_sc_hd__fill_1
XFILLER_94_256 VGND VGND VPWR VPWR sky130_fd_sc_hd__decap_3
XFILLER_48_651 VGND VGND VPWR VPWR sky130_fd_sc_hd__decap_3
XFILLER_82_429 VGND VGND VPWR VPWR sky130_fd_sc_hd__decap_3
XFILLER_63_610 VGND VGND VPWR VPWR sky130_fd_sc_hd__decap_3
XFILLER_48_684 VGND VGND VPWR VPWR sky130_fd_sc_hd__decap_3
XFILLER_47_172 VGND VGND VPWR VPWR sky130_fd_sc_hd__decap_3
XFILLER_63_632 VGND VGND VPWR VPWR sky130_fd_sc_hd__decap_3
XFILLER_35_323 VGND VGND VPWR VPWR sky130_fd_sc_hd__decap_3
XFILLER_63_665 VGND VGND VPWR VPWR sky130_fd_sc_hd__decap_3
XTAP_TAPCELL_ROW_46_863 VGND VPWR sky130_fd_sc_hd__tapvpwrvgnd_1
XFILLER_63_676 VGND VGND VPWR VPWR sky130_fd_sc_hd__decap_3
XFILLER_90_473 VGND VGND VPWR VPWR sky130_fd_sc_hd__decap_3
XFILLER_50_304 VGND VGND VPWR VPWR sky130_fd_sc_hd__fill_1
XFILLER_35_378 VGND VGND VPWR VPWR sky130_fd_sc_hd__decap_3
X_6760_ _6960_/CLK _6760_/D VGND VGND VPWR VPWR _6760_/Q sky130_fd_sc_hd__dfxtp_2
XFILLER_50_315 VGND VGND VPWR VPWR sky130_fd_sc_hd__decap_3
XFILLER_16_570 VGND VGND VPWR VPWR sky130_fd_sc_hd__decap_3
XFILLER_62_197 VGND VGND VPWR VPWR sky130_fd_sc_hd__decap_3
XFILLER_16_592 VGND VGND VPWR VPWR sky130_fd_sc_hd__decap_3
XFILLER_50_348 VGND VGND VPWR VPWR sky130_fd_sc_hd__decap_3
X_6691_ _7380_/CLK _6691_/D VGND VGND VPWR VPWR _6691_/Q sky130_fd_sc_hd__dfxtp_2
X_5642_ _5642_/A _5642_/B VGND VGND VPWR VPWR _5643_/A sky130_fd_sc_hd__or2_2
XTAP_TAPCELL_ROW_100_1571 VGND VPWR sky130_fd_sc_hd__tapvpwrvgnd_1
X_5573_ hold967/X _4983_/A _4975_/Y VGND VGND VPWR VPWR _7044_/D sky130_fd_sc_hd__o21a_2
XFILLER_117_612 VGND VGND VPWR VPWR sky130_fd_sc_hd__decap_3
XFILLER_117_623 VGND VGND VPWR VPWR sky130_fd_sc_hd__decap_3
XFILLER_116_100 VGND VGND VPWR VPWR sky130_fd_sc_hd__decap_3
X_7312_ _7345_/CLK _7312_/D _6592_/Y VGND VGND VPWR VPWR _7312_/Q sky130_fd_sc_hd__dfrtp_2
X_4524_ _4524_/A0 _7285_/Q _4528_/B VGND VGND VPWR VPWR _7317_/D sky130_fd_sc_hd__mux2_2
XFILLER_117_656 VGND VGND VPWR VPWR sky130_fd_sc_hd__decap_3
X_7243_ _7372_/CLK _7243_/D _6523_/Y VGND VGND VPWR VPWR _7243_/Q sky130_fd_sc_hd__dfrtp_2
XFILLER_104_306 VGND VGND VPWR VPWR sky130_fd_sc_hd__fill_2
X_4455_ _4069_/Y _4081_/X _4082_/X _4454_/X VGND VGND VPWR VPWR _4720_/B sky130_fd_sc_hd__o211a_2
X_3406_ _3409_/D VGND VGND VPWR VPWR _3417_/C sky130_fd_sc_hd__inv_4
X_4386_ _7305_/Q _4429_/A2 _4437_/B1 _7369_/Q _4429_/C1 VGND VGND VPWR VPWR _4386_/X
+ sky130_fd_sc_hd__a221o_2
X_7174_ _7368_/CLK _7174_/D _6454_/Y VGND VGND VPWR VPWR _7174_/Q sky130_fd_sc_hd__dfrtp_2
XFILLER_98_562 VGND VGND VPWR VPWR sky130_fd_sc_hd__decap_3
XFILLER_86_713 VGND VGND VPWR VPWR sky130_fd_sc_hd__decap_3
XFILLER_58_404 VGND VGND VPWR VPWR sky130_fd_sc_hd__decap_3
XFILLER_100_501 VGND VGND VPWR VPWR sky130_fd_sc_hd__decap_3
XFILLER_98_595 VGND VGND VPWR VPWR sky130_fd_sc_hd__decap_3
XFILLER_105_36 VGND VGND VPWR VPWR sky130_fd_sc_hd__decap_3
XFILLER_58_459 VGND VGND VPWR VPWR sky130_fd_sc_hd__decap_3
XFILLER_85_256 VGND VGND VPWR VPWR sky130_fd_sc_hd__decap_3
XFILLER_39_662 VGND VGND VPWR VPWR sky130_fd_sc_hd__decap_3
X_5007_ _5002_/Y _5003_/X _5004_/X _5005_/Y _5006_/X VGND VGND VPWR VPWR _5662_/A
+ sky130_fd_sc_hd__a221o_2
XFILLER_39_673 VGND VGND VPWR VPWR sky130_fd_sc_hd__decap_3
XFILLER_100_589 VGND VGND VPWR VPWR sky130_fd_sc_hd__decap_3
XFILLER_54_610 VGND VGND VPWR VPWR sky130_fd_sc_hd__decap_3
XFILLER_38_172 VGND VGND VPWR VPWR sky130_fd_sc_hd__decap_3
XFILLER_26_312 VGND VGND VPWR VPWR sky130_fd_sc_hd__decap_3
XFILLER_54_643 VGND VGND VPWR VPWR sky130_fd_sc_hd__fill_1
XFILLER_54_654 VGND VGND VPWR VPWR sky130_fd_sc_hd__decap_3
XFILLER_26_345 VGND VGND VPWR VPWR sky130_fd_sc_hd__decap_3
XFILLER_121_24 VGND VGND VPWR VPWR sky130_fd_sc_hd__decap_3
XFILLER_53_153 VGND VGND VPWR VPWR sky130_fd_sc_hd__fill_1
XFILLER_54_687 VGND VGND VPWR VPWR sky130_fd_sc_hd__decap_3
XFILLER_121_57 VGND VGND VPWR VPWR sky130_fd_sc_hd__decap_3
XFILLER_41_315 VGND VGND VPWR VPWR sky130_fd_sc_hd__decap_3
XFILLER_26_389 VGND VGND VPWR VPWR sky130_fd_sc_hd__decap_3
X_6958_ _7380_/CLK _6958_/D VGND VGND VPWR VPWR _6958_/Q sky130_fd_sc_hd__dfxtp_2
XFILLER_41_337 VGND VGND VPWR VPWR sky130_fd_sc_hd__decap_3
X_6889_ _7403_/CLK _6889_/D VGND VGND VPWR VPWR _6889_/Q sky130_fd_sc_hd__dfxtp_2
XTAP_TAPCELL_ROW_24_579 VGND VPWR sky130_fd_sc_hd__tapvpwrvgnd_1
XFILLER_10_713 VGND VGND VPWR VPWR sky130_fd_sc_hd__decap_3
XTAP_TAPCELL_ROW_62_1076 VGND VPWR sky130_fd_sc_hd__tapvpwrvgnd_1
XFILLER_22_584 VGND VGND VPWR VPWR sky130_fd_sc_hd__decap_3
XFILLER_22_595 VGND VGND VPWR VPWR sky130_fd_sc_hd__decap_3
XFILLER_108_601 VGND VGND VPWR VPWR sky130_fd_sc_hd__decap_3
XFILLER_6_728 VGND VGND VPWR VPWR sky130_fd_sc_hd__decap_3
XFILLER_30_21 VGND VGND VPWR VPWR sky130_fd_sc_hd__decap_3
XFILLER_108_634 VGND VGND VPWR VPWR sky130_fd_sc_hd__decap_3
XFILLER_108_645 VGND VGND VPWR VPWR sky130_fd_sc_hd__decap_3
XFILLER_107_122 VGND VGND VPWR VPWR sky130_fd_sc_hd__decap_3
XFILLER_108_678 VGND VGND VPWR VPWR sky130_fd_sc_hd__decap_3
XFILLER_107_155 VGND VGND VPWR VPWR sky130_fd_sc_hd__decap_3
XFILLER_100_3 VGND VGND VPWR VPWR sky130_fd_sc_hd__decap_3
XFILLER_122_103 VGND VGND VPWR VPWR sky130_fd_sc_hd__decap_3
XFILLER_123_659 VGND VGND VPWR VPWR sky130_fd_sc_hd__decap_3
Xhold780 _6741_/Q VGND VGND VPWR VPWR _6741_/D sky130_fd_sc_hd__dlygate4sd3_1
Xhold791 _6945_/Q VGND VGND VPWR VPWR _6945_/D sky130_fd_sc_hd__dlygate4sd3_1
XFILLER_110_309 VGND VGND VPWR VPWR sky130_fd_sc_hd__decap_3
XFILLER_89_573 VGND VGND VPWR VPWR sky130_fd_sc_hd__decap_3
XFILLER_77_724 VGND VGND VPWR VPWR sky130_fd_sc_hd__decap_3
XFILLER_39_63 VGND VGND VPWR VPWR sky130_fd_sc_hd__decap_3
XFILLER_1_499 VGND VGND VPWR VPWR sky130_fd_sc_hd__decap_3
XFILLER_76_234 VGND VGND VPWR VPWR sky130_fd_sc_hd__decap_3
XFILLER_76_256 VGND VGND VPWR VPWR sky130_fd_sc_hd__decap_3
XFILLER_92_716 VGND VGND VPWR VPWR sky130_fd_sc_hd__decap_3
XFILLER_45_610 VGND VGND VPWR VPWR sky130_fd_sc_hd__decap_3
XFILLER_91_237 VGND VGND VPWR VPWR sky130_fd_sc_hd__decap_3
XFILLER_57_492 VGND VGND VPWR VPWR sky130_fd_sc_hd__decap_3
XFILLER_45_632 VGND VGND VPWR VPWR sky130_fd_sc_hd__decap_3
XFILLER_55_73 VGND VGND VPWR VPWR sky130_fd_sc_hd__decap_3
XFILLER_45_665 VGND VGND VPWR VPWR sky130_fd_sc_hd__decap_3
XFILLER_45_676 VGND VGND VPWR VPWR sky130_fd_sc_hd__decap_3
XFILLER_17_367 VGND VGND VPWR VPWR sky130_fd_sc_hd__fill_1
XFILLER_60_613 VGND VGND VPWR VPWR sky130_fd_sc_hd__decap_3
XFILLER_72_473 VGND VGND VPWR VPWR sky130_fd_sc_hd__decap_3
XFILLER_32_315 VGND VGND VPWR VPWR sky130_fd_sc_hd__decap_3
XTAP_TAPCELL_ROW_43_822 VGND VPWR sky130_fd_sc_hd__tapvpwrvgnd_1
XFILLER_44_197 VGND VGND VPWR VPWR sky130_fd_sc_hd__decap_3
XFILLER_60_657 VGND VGND VPWR VPWR sky130_fd_sc_hd__decap_3
XFILLER_32_348 VGND VGND VPWR VPWR sky130_fd_sc_hd__decap_3
XFILLER_9_500 VGND VGND VPWR VPWR sky130_fd_sc_hd__decap_3
XFILLER_13_551 VGND VGND VPWR VPWR sky130_fd_sc_hd__decap_3
XFILLER_13_573 VGND VGND VPWR VPWR sky130_fd_sc_hd__decap_3
XFILLER_9_544 VGND VGND VPWR VPWR sky130_fd_sc_hd__decap_3
XFILLER_9_588 VGND VGND VPWR VPWR sky130_fd_sc_hd__decap_3
XFILLER_65_6 VGND VGND VPWR VPWR sky130_fd_sc_hd__decap_3
XFILLER_114_604 VGND VGND VPWR VPWR sky130_fd_sc_hd__decap_3
XFILLER_114_637 VGND VGND VPWR VPWR sky130_fd_sc_hd__decap_3
XFILLER_99_337 VGND VGND VPWR VPWR sky130_fd_sc_hd__decap_3
XFILLER_114_648 VGND VGND VPWR VPWR sky130_fd_sc_hd__decap_3
X_4240_ _4628_/A _4629_/B VGND VGND VPWR VPWR _4241_/B sky130_fd_sc_hd__and2_2
XFILLER_4_293 VGND VGND VPWR VPWR sky130_fd_sc_hd__decap_3
XFILLER_68_713 VGND VGND VPWR VPWR sky130_fd_sc_hd__decap_3
XFILLER_113_169 VGND VGND VPWR VPWR sky130_fd_sc_hd__decap_3
X_4171_ _4203_/A _4203_/B _4202_/A VGND VGND VPWR VPWR _4379_/B sky130_fd_sc_hd__a21oi_2
XFILLER_67_201 VGND VGND VPWR VPWR sky130_fd_sc_hd__decap_3
XFILLER_95_521 VGND VGND VPWR VPWR sky130_fd_sc_hd__decap_3
XFILLER_122_681 VGND VGND VPWR VPWR sky130_fd_sc_hd__decap_3
XFILLER_67_223 VGND VGND VPWR VPWR sky130_fd_sc_hd__fill_1
XFILLER_96_80 VGND VGND VPWR VPWR sky130_fd_sc_hd__decap_3
XFILLER_121_180 VGND VGND VPWR VPWR sky130_fd_sc_hd__decap_3
XFILLER_95_576 VGND VGND VPWR VPWR sky130_fd_sc_hd__decap_3
XFILLER_83_727 VGND VGND VPWR VPWR sky130_fd_sc_hd__fill_1
XFILLER_27_109 VGND VGND VPWR VPWR sky130_fd_sc_hd__decap_3
XFILLER_82_215 VGND VGND VPWR VPWR sky130_fd_sc_hd__fill_2
XFILLER_36_610 VGND VGND VPWR VPWR sky130_fd_sc_hd__decap_3
XFILLER_82_237 VGND VGND VPWR VPWR sky130_fd_sc_hd__decap_3
XFILLER_36_643 VGND VGND VPWR VPWR sky130_fd_sc_hd__fill_1
XFILLER_82_259 VGND VGND VPWR VPWR sky130_fd_sc_hd__decap_3
XFILLER_36_654 VGND VGND VPWR VPWR sky130_fd_sc_hd__decap_3
XFILLER_36_687 VGND VGND VPWR VPWR sky130_fd_sc_hd__decap_3
X_6812_ _6967_/CLK _6812_/D VGND VGND VPWR VPWR _6812_/Q sky130_fd_sc_hd__dfxtp_2
Xplace440 _5581_/S VGND VGND VPWR VPWR _5015_/A sky130_fd_sc_hd__buf_2
XFILLER_63_473 VGND VGND VPWR VPWR sky130_fd_sc_hd__decap_3
XFILLER_51_613 VGND VGND VPWR VPWR sky130_fd_sc_hd__decap_3
Xplace451 _6983_/Q VGND VGND VPWR VPWR _3561_/B sky130_fd_sc_hd__buf_2
XFILLER_35_175 VGND VGND VPWR VPWR sky130_fd_sc_hd__decap_3
XFILLER_51_635 VGND VGND VPWR VPWR sky130_fd_sc_hd__decap_3
XFILLER_90_281 VGND VGND VPWR VPWR sky130_fd_sc_hd__decap_3
XFILLER_23_337 VGND VGND VPWR VPWR sky130_fd_sc_hd__decap_3
X_6743_ clkload9/A _6743_/D VGND VGND VPWR VPWR _6743_/Q sky130_fd_sc_hd__dfxtp_2
XFILLER_51_668 VGND VGND VPWR VPWR sky130_fd_sc_hd__decap_3
XFILLER_51_679 VGND VGND VPWR VPWR sky130_fd_sc_hd__decap_3
XFILLER_50_178 VGND VGND VPWR VPWR sky130_fd_sc_hd__decap_3
X_6674_ _6674_/A VGND VGND VPWR VPWR _6674_/Y sky130_fd_sc_hd__inv_2
XTAP_TAPCELL_ROW_21_538 VGND VPWR sky130_fd_sc_hd__tapvpwrvgnd_1
X_3886_ _6920_/Q _3886_/A2 _3889_/A2 _6784_/Q VGND VGND VPWR VPWR _3886_/X sky130_fd_sc_hd__a22o_2
XFILLER_3_709 VGND VGND VPWR VPWR sky130_fd_sc_hd__decap_3
X_4507_ _4507_/A0 _7294_/Q _4520_/S VGND VGND VPWR VPWR _7326_/D sky130_fd_sc_hd__mux2_2
XFILLER_105_615 VGND VGND VPWR VPWR sky130_fd_sc_hd__fill_1
XFILLER_105_626 VGND VGND VPWR VPWR sky130_fd_sc_hd__decap_3
XFILLER_104_103 VGND VGND VPWR VPWR sky130_fd_sc_hd__fill_1
XFILLER_117_497 VGND VGND VPWR VPWR sky130_fd_sc_hd__decap_3
XFILLER_104_125 VGND VGND VPWR VPWR sky130_fd_sc_hd__decap_3
XTAP_TAPCELL_ROW_113_1740 VGND VPWR sky130_fd_sc_hd__tapvpwrvgnd_1
X_7226_ _7354_/CLK _7226_/D _6506_/Y VGND VGND VPWR VPWR _7226_/Q sky130_fd_sc_hd__dfrtp_2
XFILLER_105_659 VGND VGND VPWR VPWR sky130_fd_sc_hd__decap_3
X_4438_ _4434_/X _4437_/X _4425_/A VGND VGND VPWR VPWR _4650_/B sky130_fd_sc_hd__o21a_2
XFILLER_104_147 VGND VGND VPWR VPWR sky130_fd_sc_hd__decap_3
XFILLER_116_35 VGND VGND VPWR VPWR sky130_fd_sc_hd__decap_3
XFILLER_120_607 VGND VGND VPWR VPWR sky130_fd_sc_hd__decap_3
X_7157_ _7352_/CLK _7157_/D _6437_/Y VGND VGND VPWR VPWR _7157_/Q sky130_fd_sc_hd__dfrtp_2
XFILLER_86_510 VGND VGND VPWR VPWR sky130_fd_sc_hd__decap_3
XFILLER_76_17 VGND VGND VPWR VPWR sky130_fd_sc_hd__decap_3
XFILLER_59_724 VGND VGND VPWR VPWR sky130_fd_sc_hd__decap_3
XFILLER_116_68 VGND VGND VPWR VPWR sky130_fd_sc_hd__decap_3
X_4369_ _4369_/A _4369_/B VGND VGND VPWR VPWR _4369_/Y sky130_fd_sc_hd__nor2_2
XFILLER_98_381 VGND VGND VPWR VPWR sky130_fd_sc_hd__decap_3
XFILLER_112_180 VGND VGND VPWR VPWR sky130_fd_sc_hd__decap_3
XFILLER_100_331 VGND VGND VPWR VPWR sky130_fd_sc_hd__decap_3
X_7088_ _7355_/CLK _7088_/D _6368_/Y VGND VGND VPWR VPWR _7088_/Q sky130_fd_sc_hd__dfrtp_2
XFILLER_74_716 VGND VGND VPWR VPWR sky130_fd_sc_hd__decap_3
XFILLER_100_353 VGND VGND VPWR VPWR sky130_fd_sc_hd__decap_3
XFILLER_86_598 VGND VGND VPWR VPWR sky130_fd_sc_hd__decap_3
XFILLER_73_215 VGND VGND VPWR VPWR sky130_fd_sc_hd__decap_3
XPHY_EDGE_ROW_85_Left_209 VGND VGND VPWR VPWR sky130_fd_sc_hd__decap_3
XTAP_TAPCELL_ROW_29_638 VGND VPWR sky130_fd_sc_hd__tapvpwrvgnd_1
XFILLER_73_237 VGND VGND VPWR VPWR sky130_fd_sc_hd__decap_3
XTAP_TAPCELL_ROW_29_649 VGND VPWR sky130_fd_sc_hd__tapvpwrvgnd_1
XFILLER_39_492 VGND VGND VPWR VPWR sky130_fd_sc_hd__fill_2
XFILLER_27_632 VGND VGND VPWR VPWR sky130_fd_sc_hd__decap_3
XFILLER_26_120 VGND VGND VPWR VPWR sky130_fd_sc_hd__fill_2
XFILLER_27_665 VGND VGND VPWR VPWR sky130_fd_sc_hd__decap_3
XTAP_TAPCELL_ROW_1_274 VGND VPWR sky130_fd_sc_hd__tapvpwrvgnd_1
XFILLER_27_676 VGND VGND VPWR VPWR sky130_fd_sc_hd__decap_3
XTAP_TAPCELL_ROW_1_285 VGND VPWR sky130_fd_sc_hd__tapvpwrvgnd_1
XTAP_TAPCELL_ROW_64_1105 VGND VPWR sky130_fd_sc_hd__tapvpwrvgnd_1
XFILLER_42_613 VGND VGND VPWR VPWR sky130_fd_sc_hd__decap_3
XFILLER_14_315 VGND VGND VPWR VPWR sky130_fd_sc_hd__fill_2
XFILLER_81_281 VGND VGND VPWR VPWR sky130_fd_sc_hd__decap_3
XFILLER_81_292 VGND VGND VPWR VPWR sky130_fd_sc_hd__decap_3
XFILLER_26_197 VGND VGND VPWR VPWR sky130_fd_sc_hd__decap_3
XFILLER_42_657 VGND VGND VPWR VPWR sky130_fd_sc_hd__decap_3
XFILLER_25_65 VGND VGND VPWR VPWR sky130_fd_sc_hd__fill_1
XFILLER_50_690 VGND VGND VPWR VPWR sky130_fd_sc_hd__decap_3
XFILLER_22_381 VGND VGND VPWR VPWR sky130_fd_sc_hd__decap_3
XFILLER_41_31 VGND VGND VPWR VPWR sky130_fd_sc_hd__decap_3
XFILLER_10_554 VGND VGND VPWR VPWR sky130_fd_sc_hd__decap_3
XPHY_EDGE_ROW_94_Left_218 VGND VGND VPWR VPWR sky130_fd_sc_hd__decap_3
XFILLER_6_536 VGND VGND VPWR VPWR sky130_fd_sc_hd__decap_3
XFILLER_10_587 VGND VGND VPWR VPWR sky130_fd_sc_hd__fill_1
XFILLER_41_86 VGND VGND VPWR VPWR sky130_fd_sc_hd__decap_3
XFILLER_10_598 VGND VGND VPWR VPWR sky130_fd_sc_hd__decap_3
XFILLER_6_569 VGND VGND VPWR VPWR sky130_fd_sc_hd__decap_3
XFILLER_108_464 VGND VGND VPWR VPWR sky130_fd_sc_hd__fill_1
XFILLER_108_486 VGND VGND VPWR VPWR sky130_fd_sc_hd__decap_3
XTAP_TAPCELL_ROW_75_1245 VGND VPWR sky130_fd_sc_hd__tapvpwrvgnd_1
XFILLER_2_731 VGND VGND VPWR VPWR sky130_fd_sc_hd__decap_3
XFILLER_123_467 VGND VGND VPWR VPWR sky130_fd_sc_hd__decap_3
XTAP_TAPCELL_ROW_9_385 VGND VPWR sky130_fd_sc_hd__tapvpwrvgnd_1
XFILLER_96_318 VGND VGND VPWR VPWR sky130_fd_sc_hd__decap_3
XFILLER_1_252 VGND VGND VPWR VPWR sky130_fd_sc_hd__decap_3
XFILLER_111_629 VGND VGND VPWR VPWR sky130_fd_sc_hd__decap_3
XFILLER_1_263 VGND VGND VPWR VPWR sky130_fd_sc_hd__fill_1
XFILLER_104_681 VGND VGND VPWR VPWR sky130_fd_sc_hd__decap_3
XFILLER_49_223 VGND VGND VPWR VPWR sky130_fd_sc_hd__fill_1
XFILLER_49_234 VGND VGND VPWR VPWR sky130_fd_sc_hd__decap_3
XFILLER_92_502 VGND VGND VPWR VPWR sky130_fd_sc_hd__decap_3
XFILLER_2_69 VGND VGND VPWR VPWR sky130_fd_sc_hd__decap_3
XFILLER_65_727 VGND VGND VPWR VPWR sky130_fd_sc_hd__fill_1
XFILLER_49_278 VGND VGND VPWR VPWR sky130_fd_sc_hd__fill_2
XFILLER_66_61 VGND VGND VPWR VPWR sky130_fd_sc_hd__decap_3
XFILLER_64_215 VGND VGND VPWR VPWR sky130_fd_sc_hd__decap_3
XFILLER_18_610 VGND VGND VPWR VPWR sky130_fd_sc_hd__decap_3
XFILLER_64_248 VGND VGND VPWR VPWR sky130_fd_sc_hd__decap_3
XFILLER_18_643 VGND VGND VPWR VPWR sky130_fd_sc_hd__fill_1
XFILLER_92_568 VGND VGND VPWR VPWR sky130_fd_sc_hd__decap_3
XFILLER_64_259 VGND VGND VPWR VPWR sky130_fd_sc_hd__decap_3
XFILLER_18_654 VGND VGND VPWR VPWR sky130_fd_sc_hd__decap_3
XFILLER_80_719 VGND VGND VPWR VPWR sky130_fd_sc_hd__decap_3
XFILLER_33_602 VGND VGND VPWR VPWR sky130_fd_sc_hd__decap_3
XFILLER_45_473 VGND VGND VPWR VPWR sky130_fd_sc_hd__decap_3
XFILLER_18_687 VGND VGND VPWR VPWR sky130_fd_sc_hd__decap_3
XFILLER_17_164 VGND VGND VPWR VPWR sky130_fd_sc_hd__decap_3
XTAP_TAPCELL_ROW_86_1385 VGND VPWR sky130_fd_sc_hd__tapvpwrvgnd_1
XFILLER_60_410 VGND VGND VPWR VPWR sky130_fd_sc_hd__decap_3
XTAP_TAPCELL_ROW_56_991 VGND VPWR sky130_fd_sc_hd__tapvpwrvgnd_1
XFILLER_33_635 VGND VGND VPWR VPWR sky130_fd_sc_hd__decap_3
XFILLER_33_668 VGND VGND VPWR VPWR sky130_fd_sc_hd__decap_3
XFILLER_32_134 VGND VGND VPWR VPWR sky130_fd_sc_hd__decap_3
XFILLER_60_454 VGND VGND VPWR VPWR sky130_fd_sc_hd__fill_1
XFILLER_33_679 VGND VGND VPWR VPWR sky130_fd_sc_hd__decap_3
XFILLER_32_167 VGND VGND VPWR VPWR sky130_fd_sc_hd__decap_3
XFILLER_20_307 VGND VGND VPWR VPWR sky130_fd_sc_hd__fill_1
X_3740_ _6710_/Q _3917_/A2 _3912_/B1 _6888_/Q _3739_/X VGND VGND VPWR VPWR _3740_/X
+ sky130_fd_sc_hd__a221o_2
XFILLER_60_498 VGND VGND VPWR VPWR sky130_fd_sc_hd__decap_3
XFILLER_119_718 VGND VGND VPWR VPWR sky130_fd_sc_hd__decap_3
XFILLER_119_729 VGND VGND VPWR VPWR sky130_fd_sc_hd__decap_3
X_3671_ _3671_/A1 _4799_/A _3670_/X VGND VGND VPWR VPWR _7405_/D sky130_fd_sc_hd__o21a_2
XFILLER_63_3 VGND VGND VPWR VPWR sky130_fd_sc_hd__decap_3
X_6390_ _6581_/A VGND VGND VPWR VPWR _6390_/Y sky130_fd_sc_hd__inv_2
XFILLER_5_591 VGND VGND VPWR VPWR sky130_fd_sc_hd__decap_3
X_5272_ _5272_/A0 _5061_/X _5292_/S VGND VGND VPWR VPWR _7194_/D sky130_fd_sc_hd__mux2_2
XFILLER_102_607 VGND VGND VPWR VPWR sky130_fd_sc_hd__decap_3
X_7011_ _7355_/CLK _7011_/D _6291_/Y VGND VGND VPWR VPWR _7011_/Q sky130_fd_sc_hd__dfrtp_2
XFILLER_87_318 VGND VGND VPWR VPWR sky130_fd_sc_hd__fill_2
X_4223_ _4217_/X _4219_/X _4222_/X _4327_/A VGND VGND VPWR VPWR _4224_/C sky130_fd_sc_hd__o31a_2
XFILLER_101_128 VGND VGND VPWR VPWR sky130_fd_sc_hd__decap_3
X_4154_ _7047_/Q _4429_/A2 _4268_/B1 _7394_/Q _4153_/X VGND VGND VPWR VPWR _4154_/X
+ sky130_fd_sc_hd__a221o_2
XFILLER_110_640 VGND VGND VPWR VPWR sky130_fd_sc_hd__decap_3
XFILLER_95_340 VGND VGND VPWR VPWR sky130_fd_sc_hd__decap_3
XFILLER_110_651 VGND VGND VPWR VPWR sky130_fd_sc_hd__decap_3
XFILLER_83_502 VGND VGND VPWR VPWR sky130_fd_sc_hd__fill_2
XFILLER_56_716 VGND VGND VPWR VPWR sky130_fd_sc_hd__decap_3
XFILLER_68_587 VGND VGND VPWR VPWR sky130_fd_sc_hd__fill_1
XFILLER_110_684 VGND VGND VPWR VPWR sky130_fd_sc_hd__decap_3
X_4085_ _7238_/Q _4421_/A2 _4428_/B1 _7142_/Q _4084_/X VGND VGND VPWR VPWR _4085_/X
+ sky130_fd_sc_hd__a221o_2
XFILLER_83_579 VGND VGND VPWR VPWR sky130_fd_sc_hd__decap_3
XTAP_TAPCELL_ROW_26_608 VGND VPWR sky130_fd_sc_hd__tapvpwrvgnd_1
XFILLER_70_218 VGND VGND VPWR VPWR sky130_fd_sc_hd__fill_2
XFILLER_36_473 VGND VGND VPWR VPWR sky130_fd_sc_hd__decap_3
XFILLER_24_613 VGND VGND VPWR VPWR sky130_fd_sc_hd__decap_3
XFILLER_102_48 VGND VGND VPWR VPWR sky130_fd_sc_hd__decap_3
XFILLER_36_495 VGND VGND VPWR VPWR sky130_fd_sc_hd__decap_3
XFILLER_102_59 VGND VGND VPWR VPWR sky130_fd_sc_hd__decap_3
XFILLER_24_657 VGND VGND VPWR VPWR sky130_fd_sc_hd__decap_3
XFILLER_23_123 VGND VGND VPWR VPWR sky130_fd_sc_hd__fill_1
Xplace270 _5116_/Y VGND VGND VPWR VPWR _5658_/D sky130_fd_sc_hd__buf_2
Xplace281 _3665_/X VGND VGND VPWR VPWR _3871_/B1 sky130_fd_sc_hd__buf_2
X_4987_ _4987_/A _4987_/B VGND VGND VPWR VPWR _4987_/Y sky130_fd_sc_hd__xnor2_2
Xplace292 _3917_/A2 VGND VGND VPWR VPWR _3767_/A2 sky130_fd_sc_hd__buf_2
XFILLER_51_476 VGND VGND VPWR VPWR sky130_fd_sc_hd__decap_3
XFILLER_23_167 VGND VGND VPWR VPWR sky130_fd_sc_hd__fill_1
XFILLER_11_307 VGND VGND VPWR VPWR sky130_fd_sc_hd__decap_3
XFILLER_23_178 VGND VGND VPWR VPWR sky130_fd_sc_hd__fill_2
X_6726_ clkload5/A _6726_/D VGND VGND VPWR VPWR _6726_/Q sky130_fd_sc_hd__dfxtp_2
XFILLER_32_690 VGND VGND VPWR VPWR sky130_fd_sc_hd__decap_3
X_6657_ _6658_/A VGND VGND VPWR VPWR _6657_/Y sky130_fd_sc_hd__inv_2
X_3869_ _6772_/Q _3884_/A2 _3883_/B1 _6766_/Q VGND VGND VPWR VPWR _3869_/X sky130_fd_sc_hd__a22o_2
XFILLER_109_228 VGND VGND VPWR VPWR sky130_fd_sc_hd__decap_3
X_6588_ _6588_/A VGND VGND VPWR VPWR _6588_/Y sky130_fd_sc_hd__inv_2
XFILLER_3_517 VGND VGND VPWR VPWR sky130_fd_sc_hd__decap_3
XFILLER_87_27 VGND VGND VPWR VPWR sky130_fd_sc_hd__decap_3
XFILLER_78_318 VGND VGND VPWR VPWR sky130_fd_sc_hd__fill_1
X_7209_ _7405_/CLK _7209_/D _6489_/Y VGND VGND VPWR VPWR _7209_/Q sky130_fd_sc_hd__dfrtp_2
XTAP_TAPCELL_ROW_6_344 VGND VPWR sky130_fd_sc_hd__tapvpwrvgnd_1
XTAP_TAPCELL_ROW_70_1175 VGND VPWR sky130_fd_sc_hd__tapvpwrvgnd_1
XFILLER_101_662 VGND VGND VPWR VPWR sky130_fd_sc_hd__decap_3
XFILLER_47_727 VGND VGND VPWR VPWR sky130_fd_sc_hd__fill_1
XFILLER_101_673 VGND VGND VPWR VPWR sky130_fd_sc_hd__decap_3
XFILLER_74_524 VGND VGND VPWR VPWR sky130_fd_sc_hd__decap_3
XFILLER_46_237 VGND VGND VPWR VPWR sky130_fd_sc_hd__decap_3
XFILLER_100_183 VGND VGND VPWR VPWR sky130_fd_sc_hd__decap_3
XFILLER_46_259 VGND VGND VPWR VPWR sky130_fd_sc_hd__decap_3
XFILLER_62_719 VGND VGND VPWR VPWR sky130_fd_sc_hd__decap_3
XFILLER_36_53 VGND VGND VPWR VPWR sky130_fd_sc_hd__fill_2
XFILLER_27_462 VGND VGND VPWR VPWR sky130_fd_sc_hd__decap_3
XFILLER_61_218 VGND VGND VPWR VPWR sky130_fd_sc_hd__fill_1
XFILLER_15_635 VGND VGND VPWR VPWR sky130_fd_sc_hd__decap_3
XFILLER_54_281 VGND VGND VPWR VPWR sky130_fd_sc_hd__decap_3
XFILLER_42_421 VGND VGND VPWR VPWR sky130_fd_sc_hd__decap_3
XFILLER_42_443 VGND VGND VPWR VPWR sky130_fd_sc_hd__fill_2
XTAP_TAPCELL_ROW_53_950 VGND VPWR sky130_fd_sc_hd__tapvpwrvgnd_1
XFILLER_42_454 VGND VGND VPWR VPWR sky130_fd_sc_hd__decap_3
XFILLER_15_668 VGND VGND VPWR VPWR sky130_fd_sc_hd__decap_3
XTAP_TAPCELL_ROW_53_961 VGND VPWR sky130_fd_sc_hd__tapvpwrvgnd_1
XFILLER_15_679 VGND VGND VPWR VPWR sky130_fd_sc_hd__decap_3
XFILLER_30_616 VGND VGND VPWR VPWR sky130_fd_sc_hd__decap_3
XFILLER_52_85 VGND VGND VPWR VPWR sky130_fd_sc_hd__decap_3
XFILLER_10_340 VGND VGND VPWR VPWR sky130_fd_sc_hd__decap_3
XFILLER_10_395 VGND VGND VPWR VPWR sky130_fd_sc_hd__fill_1
XFILLER_108_261 VGND VGND VPWR VPWR sky130_fd_sc_hd__decap_3
XFILLER_123_253 VGND VGND VPWR VPWR sky130_fd_sc_hd__decap_3
XFILLER_97_638 VGND VGND VPWR VPWR sky130_fd_sc_hd__decap_3
XFILLER_2_572 VGND VGND VPWR VPWR sky130_fd_sc_hd__decap_3
XFILLER_96_126 VGND VGND VPWR VPWR sky130_fd_sc_hd__fill_1
XFILLER_77_60 VGND VGND VPWR VPWR sky130_fd_sc_hd__fill_2
XFILLER_77_340 VGND VGND VPWR VPWR sky130_fd_sc_hd__decap_3
XFILLER_38_716 VGND VGND VPWR VPWR sky130_fd_sc_hd__decap_3
XTAP_TAPCELL_ROW_88_1414 VGND VPWR sky130_fd_sc_hd__tapvpwrvgnd_1
XFILLER_37_215 VGND VGND VPWR VPWR sky130_fd_sc_hd__fill_1
XFILLER_37_237 VGND VGND VPWR VPWR sky130_fd_sc_hd__decap_3
XFILLER_92_365 VGND VGND VPWR VPWR sky130_fd_sc_hd__decap_3
XFILLER_18_451 VGND VGND VPWR VPWR sky130_fd_sc_hd__decap_3
X_4910_ _4910_/A _4910_/B VGND VGND VPWR VPWR _4910_/Y sky130_fd_sc_hd__nand2_2
XFILLER_92_398 VGND VGND VPWR VPWR sky130_fd_sc_hd__decap_3
XFILLER_33_432 VGND VGND VPWR VPWR sky130_fd_sc_hd__decap_3
X_4841_ _4890_/B _4888_/B VGND VGND VPWR VPWR _4841_/Y sky130_fd_sc_hd__nand2b_2
XFILLER_60_262 VGND VGND VPWR VPWR sky130_fd_sc_hd__decap_3
XFILLER_33_476 VGND VGND VPWR VPWR sky130_fd_sc_hd__fill_1
XFILLER_33_487 VGND VGND VPWR VPWR sky130_fd_sc_hd__decap_3
XFILLER_21_638 VGND VGND VPWR VPWR sky130_fd_sc_hd__decap_3
X_4772_ _4772_/A0 _4771_/X _4837_/S VGND VGND VPWR VPWR _7275_/D sky130_fd_sc_hd__mux2_2
XFILLER_60_295 VGND VGND VPWR VPWR sky130_fd_sc_hd__fill_1
XFILLER_14_690 VGND VGND VPWR VPWR sky130_fd_sc_hd__decap_3
X_6511_ _6610_/A VGND VGND VPWR VPWR _6511_/Y sky130_fd_sc_hd__inv_2
X_3723_ _6813_/Q _3878_/A2 _3878_/B1 _6823_/Q VGND VGND VPWR VPWR _3723_/X sky130_fd_sc_hd__a22o_2
XFILLER_20_159 VGND VGND VPWR VPWR sky130_fd_sc_hd__fill_1
XTAP_TAPCELL_ROW_31_666 VGND VPWR sky130_fd_sc_hd__tapvpwrvgnd_1
XFILLER_119_526 VGND VGND VPWR VPWR sky130_fd_sc_hd__decap_3
XTAP_TAPCELL_ROW_99_1554 VGND VPWR sky130_fd_sc_hd__tapvpwrvgnd_1
XFILLER_9_182 VGND VGND VPWR VPWR sky130_fd_sc_hd__decap_3
XFILLER_119_559 VGND VGND VPWR VPWR sky130_fd_sc_hd__fill_1
X_6442_ _6640_/A VGND VGND VPWR VPWR _6442_/Y sky130_fd_sc_hd__inv_2
XFILLER_106_209 VGND VGND VPWR VPWR sky130_fd_sc_hd__decap_3
X_6373_ _6566_/A VGND VGND VPWR VPWR _6373_/Y sky130_fd_sc_hd__inv_2
XFILLER_115_721 VGND VGND VPWR VPWR sky130_fd_sc_hd__decap_3
X_3585_ _3591_/A _3591_/B _3591_/C _3586_/D VGND VGND VPWR VPWR _3599_/A sky130_fd_sc_hd__o31a_2
XFILLER_115_732 VGND VGND VPWR VPWR sky130_fd_sc_hd__decap_3
XFILLER_88_616 VGND VGND VPWR VPWR sky130_fd_sc_hd__decap_3
XFILLER_114_253 VGND VGND VPWR VPWR sky130_fd_sc_hd__decap_3
XFILLER_102_404 VGND VGND VPWR VPWR sky130_fd_sc_hd__fill_2
XFILLER_87_137 VGND VGND VPWR VPWR sky130_fd_sc_hd__decap_3
X_4206_ _4920_/A _4204_/Y _4205_/X VGND VGND VPWR VPWR _4206_/X sky130_fd_sc_hd__a21o_2
XFILLER_68_340 VGND VGND VPWR VPWR sky130_fd_sc_hd__fill_1
XTAP_TAPCELL_ROW_3_303 VGND VPWR sky130_fd_sc_hd__tapvpwrvgnd_1
X_5186_ _5186_/A _5207_/B VGND VGND VPWR VPWR _7235_/D sky130_fd_sc_hd__and2_2
XFILLER_96_660 VGND VGND VPWR VPWR sky130_fd_sc_hd__decap_3
XFILLER_68_362 VGND VGND VPWR VPWR sky130_fd_sc_hd__fill_2
XFILLER_29_727 VGND VGND VPWR VPWR sky130_fd_sc_hd__fill_1
X_4137_ _7048_/Q _4429_/A2 _4399_/A2 _7395_/Q _4136_/X VGND VGND VPWR VPWR _4137_/X
+ sky130_fd_sc_hd__a221o_2
XFILLER_96_693 VGND VGND VPWR VPWR sky130_fd_sc_hd__decap_3
XFILLER_28_248 VGND VGND VPWR VPWR sky130_fd_sc_hd__decap_3
XFILLER_113_36 VGND VGND VPWR VPWR sky130_fd_sc_hd__decap_3
XFILLER_83_343 VGND VGND VPWR VPWR sky130_fd_sc_hd__decap_3
XFILLER_28_259 VGND VGND VPWR VPWR sky130_fd_sc_hd__decap_3
XFILLER_44_719 VGND VGND VPWR VPWR sky130_fd_sc_hd__decap_3
X_4068_ _4068_/A _4082_/A VGND VGND VPWR VPWR _4069_/B sky130_fd_sc_hd__nor2_2
XFILLER_73_18 VGND VGND VPWR VPWR sky130_fd_sc_hd__decap_3
XFILLER_113_69 VGND VGND VPWR VPWR sky130_fd_sc_hd__decap_3
XTAP_TAPCELL_ROW_39_777 VGND VPWR sky130_fd_sc_hd__tapvpwrvgnd_1
XFILLER_71_516 VGND VGND VPWR VPWR sky130_fd_sc_hd__decap_3
XTAP_TAPCELL_ROW_108_1672 VGND VPWR sky130_fd_sc_hd__tapvpwrvgnd_1
XFILLER_24_421 VGND VGND VPWR VPWR sky130_fd_sc_hd__decap_3
XFILLER_36_292 VGND VGND VPWR VPWR sky130_fd_sc_hd__decap_3
XFILLER_51_240 VGND VGND VPWR VPWR sky130_fd_sc_hd__fill_1
XFILLER_12_616 VGND VGND VPWR VPWR sky130_fd_sc_hd__decap_3
XFILLER_51_273 VGND VGND VPWR VPWR sky130_fd_sc_hd__decap_3
XTAP_TAPCELL_ROW_50_920 VGND VPWR sky130_fd_sc_hd__tapvpwrvgnd_1
X_6709_ _7403_/CLK _6709_/D VGND VGND VPWR VPWR _6709_/Q sky130_fd_sc_hd__dfxtp_2
XFILLER_11_159 VGND VGND VPWR VPWR sky130_fd_sc_hd__decap_3
XFILLER_20_660 VGND VGND VPWR VPWR sky130_fd_sc_hd__decap_3
XFILLER_20_693 VGND VGND VPWR VPWR sky130_fd_sc_hd__decap_3
XFILLER_22_88 VGND VGND VPWR VPWR sky130_fd_sc_hd__decap_3
XTAP_TAPCELL_ROW_59_1037 VGND VPWR sky130_fd_sc_hd__tapvpwrvgnd_1
XFILLER_106_710 VGND VGND VPWR VPWR sky130_fd_sc_hd__decap_3
XFILLER_3_303 VGND VGND VPWR VPWR sky130_fd_sc_hd__decap_3
XFILLER_118_581 VGND VGND VPWR VPWR sky130_fd_sc_hd__decap_3
XFILLER_118_592 VGND VGND VPWR VPWR sky130_fd_sc_hd__decap_3
XFILLER_98_59 VGND VGND VPWR VPWR sky130_fd_sc_hd__decap_3
XTAP_TAPCELL_ROW_72_1204 VGND VPWR sky130_fd_sc_hd__tapvpwrvgnd_1
XFILLER_105_231 VGND VGND VPWR VPWR sky130_fd_sc_hd__decap_3
XFILLER_105_253 VGND VGND VPWR VPWR sky130_fd_sc_hd__fill_1
XFILLER_79_638 VGND VGND VPWR VPWR sky130_fd_sc_hd__decap_3
XFILLER_121_724 VGND VGND VPWR VPWR sky130_fd_sc_hd__decap_3
XFILLER_78_115 VGND VGND VPWR VPWR sky130_fd_sc_hd__decap_3
XFILLER_120_212 VGND VGND VPWR VPWR sky130_fd_sc_hd__decap_3
Xoutput490 _5658_/D VGND VGND VPWR VPWR alu_result_out[7] sky130_fd_sc_hd__clkdlybuf4s25_1
XFILLER_59_340 VGND VGND VPWR VPWR sky130_fd_sc_hd__decap_3
XFILLER_94_619 VGND VGND VPWR VPWR sky130_fd_sc_hd__decap_3
XFILLER_87_671 VGND VGND VPWR VPWR sky130_fd_sc_hd__fill_1
XFILLER_87_682 VGND VGND VPWR VPWR sky130_fd_sc_hd__decap_3
XFILLER_19_215 VGND VGND VPWR VPWR sky130_fd_sc_hd__decap_3
XFILLER_101_470 VGND VGND VPWR VPWR sky130_fd_sc_hd__decap_3
XFILLER_86_181 VGND VGND VPWR VPWR sky130_fd_sc_hd__decap_3
XFILLER_74_354 VGND VGND VPWR VPWR sky130_fd_sc_hd__decap_3
XFILLER_74_365 VGND VGND VPWR VPWR sky130_fd_sc_hd__decap_3
XFILLER_47_579 VGND VGND VPWR VPWR sky130_fd_sc_hd__fill_1
XFILLER_34_207 VGND VGND VPWR VPWR sky130_fd_sc_hd__decap_3
XFILLER_74_398 VGND VGND VPWR VPWR sky130_fd_sc_hd__fill_1
XFILLER_27_281 VGND VGND VPWR VPWR sky130_fd_sc_hd__decap_3
XTAP_TAPCELL_ROW_83_1344 VGND VPWR sky130_fd_sc_hd__tapvpwrvgnd_1
XFILLER_15_487 VGND VGND VPWR VPWR sky130_fd_sc_hd__decap_3
XFILLER_30_424 VGND VGND VPWR VPWR sky130_fd_sc_hd__decap_3
XFILLER_8_24 VGND VGND VPWR VPWR sky130_fd_sc_hd__decap_3
XFILLER_8_57 VGND VGND VPWR VPWR sky130_fd_sc_hd__decap_3
XFILLER_7_620 VGND VGND VPWR VPWR sky130_fd_sc_hd__decap_3
XFILLER_11_671 VGND VGND VPWR VPWR sky130_fd_sc_hd__fill_1
XFILLER_11_682 VGND VGND VPWR VPWR sky130_fd_sc_hd__decap_3
XFILLER_7_653 VGND VGND VPWR VPWR sky130_fd_sc_hd__decap_3
Xwire573 _6370_/A VGND VGND VPWR VPWR _6568_/A sky130_fd_sc_hd__buf_2
XFILLER_116_518 VGND VGND VPWR VPWR sky130_fd_sc_hd__decap_3
Xhold609 _6959_/Q VGND VGND VPWR VPWR _6959_/D sky130_fd_sc_hd__dlygate4sd3_1
XFILLER_109_570 VGND VGND VPWR VPWR sky130_fd_sc_hd__decap_3
XFILLER_7_697 VGND VGND VPWR VPWR sky130_fd_sc_hd__decap_3
XFILLER_6_185 VGND VGND VPWR VPWR sky130_fd_sc_hd__decap_3
X_3370_ _3386_/A _6983_/Q VGND VGND VPWR VPWR _3370_/Y sky130_fd_sc_hd__nor2_2
XTAP_TAPCELL_ROW_94_1484 VGND VPWR sky130_fd_sc_hd__tapvpwrvgnd_1
XTAP_TAPCELL_ROW_94_1495 VGND VPWR sky130_fd_sc_hd__tapvpwrvgnd_1
XFILLER_112_713 VGND VGND VPWR VPWR sky130_fd_sc_hd__decap_3
XFILLER_97_413 VGND VGND VPWR VPWR sky130_fd_sc_hd__decap_3
XFILLER_111_212 VGND VGND VPWR VPWR sky130_fd_sc_hd__decap_3
X_5040_ _6989_/D _5039_/X _5040_/S VGND VGND VPWR VPWR _5040_/X sky130_fd_sc_hd__mux2_2
XFILLER_26_3 VGND VGND VPWR VPWR sky130_fd_sc_hd__decap_3
XFILLER_111_256 VGND VGND VPWR VPWR sky130_fd_sc_hd__decap_3
XFILLER_78_660 VGND VGND VPWR VPWR sky130_fd_sc_hd__decap_3
XFILLER_84_107 VGND VGND VPWR VPWR sky130_fd_sc_hd__fill_1
XFILLER_78_693 VGND VGND VPWR VPWR sky130_fd_sc_hd__decap_3
XFILLER_77_181 VGND VGND VPWR VPWR sky130_fd_sc_hd__decap_3
XFILLER_93_641 VGND VGND VPWR VPWR sky130_fd_sc_hd__decap_3
XFILLER_65_343 VGND VGND VPWR VPWR sky130_fd_sc_hd__decap_3
XFILLER_53_505 VGND VGND VPWR VPWR sky130_fd_sc_hd__decap_3
XFILLER_26_719 VGND VGND VPWR VPWR sky130_fd_sc_hd__decap_3
X_6991_ _7398_/CLK _6991_/D _6271_/Y VGND VGND VPWR VPWR _6991_/Q sky130_fd_sc_hd__dfrtp_2
XFILLER_93_685 VGND VGND VPWR VPWR sky130_fd_sc_hd__decap_3
XTAP_TAPCELL_ROW_36_736 VGND VPWR sky130_fd_sc_hd__tapvpwrvgnd_1
XFILLER_80_324 VGND VGND VPWR VPWR sky130_fd_sc_hd__fill_1
XFILLER_92_195 VGND VGND VPWR VPWR sky130_fd_sc_hd__fill_1
XFILLER_33_240 VGND VGND VPWR VPWR sky130_fd_sc_hd__decap_3
XFILLER_33_262 VGND VGND VPWR VPWR sky130_fd_sc_hd__fill_2
XTAP_TAPCELL_ROW_16_471 VGND VPWR sky130_fd_sc_hd__tapvpwrvgnd_1
XFILLER_21_435 VGND VGND VPWR VPWR sky130_fd_sc_hd__decap_3
X_4755_ _7005_/Q _4775_/A VGND VGND VPWR VPWR _7005_/D sky130_fd_sc_hd__xor2_2
X_4686_ _6999_/Q _7000_/Q _4858_/B VGND VGND VPWR VPWR _4687_/B sky130_fd_sc_hd__and3_2
XFILLER_107_529 VGND VGND VPWR VPWR sky130_fd_sc_hd__decap_3
X_6425_ _6649_/A VGND VGND VPWR VPWR _6425_/Y sky130_fd_sc_hd__inv_2
X_3637_ _3636_/Y _5146_/B1 _3505_/X _3618_/X VGND VGND VPWR VPWR _3637_/X sky130_fd_sc_hd__a22o_2
XFILLER_108_14 VGND VGND VPWR VPWR sky130_fd_sc_hd__decap_3
XFILLER_108_47 VGND VGND VPWR VPWR sky130_fd_sc_hd__decap_3
X_6356_ _6684_/A VGND VGND VPWR VPWR _6356_/Y sky130_fd_sc_hd__inv_2
X_3568_ _7093_/Q _3417_/X _3407_/X _7125_/Q VGND VGND VPWR VPWR _3568_/X sky130_fd_sc_hd__a22o_2
XFILLER_88_413 VGND VGND VPWR VPWR sky130_fd_sc_hd__decap_3
XFILLER_68_29 VGND VGND VPWR VPWR sky130_fd_sc_hd__decap_3
XFILLER_115_573 VGND VGND VPWR VPWR sky130_fd_sc_hd__decap_3
XFILLER_0_317 VGND VGND VPWR VPWR sky130_fd_sc_hd__decap_3
XFILLER_88_424 VGND VGND VPWR VPWR sky130_fd_sc_hd__decap_3
XFILLER_103_724 VGND VGND VPWR VPWR sky130_fd_sc_hd__decap_3
XFILLER_102_201 VGND VGND VPWR VPWR sky130_fd_sc_hd__decap_3
X_6287_ _6288_/A VGND VGND VPWR VPWR _6287_/Y sky130_fd_sc_hd__inv_2
X_3499_ _4289_/A _5688_/S _3497_/X _5152_/B VGND VGND VPWR VPWR _3541_/B sky130_fd_sc_hd__a31oi_4
X_5238_ _5362_/C _5238_/B _5229_/C VGND VGND VPWR VPWR _5238_/X sky130_fd_sc_hd__or3b_2
XFILLER_76_619 VGND VGND VPWR VPWR sky130_fd_sc_hd__decap_3
XFILLER_69_671 VGND VGND VPWR VPWR sky130_fd_sc_hd__fill_1
XFILLER_69_682 VGND VGND VPWR VPWR sky130_fd_sc_hd__decap_3
XFILLER_102_289 VGND VGND VPWR VPWR sky130_fd_sc_hd__decap_3
X_5169_ _5169_/A _5200_/B VGND VGND VPWR VPWR _7243_/D sky130_fd_sc_hd__and2_2
XFILLER_29_568 VGND VGND VPWR VPWR sky130_fd_sc_hd__decap_3
XFILLER_84_663 VGND VGND VPWR VPWR sky130_fd_sc_hd__decap_3
XFILLER_56_365 VGND VGND VPWR VPWR sky130_fd_sc_hd__decap_3
XFILLER_44_505 VGND VGND VPWR VPWR sky130_fd_sc_hd__decap_3
XFILLER_17_22 VGND VGND VPWR VPWR sky130_fd_sc_hd__decap_3
XFILLER_71_302 VGND VGND VPWR VPWR sky130_fd_sc_hd__decap_3
XFILLER_16_207 VGND VGND VPWR VPWR sky130_fd_sc_hd__decap_3
XFILLER_84_696 VGND VGND VPWR VPWR sky130_fd_sc_hd__decap_3
XFILLER_83_162 VGND VGND VPWR VPWR sky130_fd_sc_hd__decap_3
XFILLER_24_251 VGND VGND VPWR VPWR sky130_fd_sc_hd__fill_1
XFILLER_33_10 VGND VGND VPWR VPWR sky130_fd_sc_hd__fill_2
XFILLER_24_262 VGND VGND VPWR VPWR sky130_fd_sc_hd__decap_3
XFILLER_40_722 VGND VGND VPWR VPWR sky130_fd_sc_hd__decap_3
XFILLER_12_424 VGND VGND VPWR VPWR sky130_fd_sc_hd__decap_3
XFILLER_24_295 VGND VGND VPWR VPWR sky130_fd_sc_hd__decap_3
XFILLER_12_446 VGND VGND VPWR VPWR sky130_fd_sc_hd__decap_3
XFILLER_12_468 VGND VGND VPWR VPWR sky130_fd_sc_hd__decap_3
XFILLER_20_490 VGND VGND VPWR VPWR sky130_fd_sc_hd__decap_3
XFILLER_4_601 VGND VGND VPWR VPWR sky130_fd_sc_hd__decap_3
XFILLER_4_634 VGND VGND VPWR VPWR sky130_fd_sc_hd__decap_3
XFILLER_4_645 VGND VGND VPWR VPWR sky130_fd_sc_hd__decap_3
XFILLER_106_551 VGND VGND VPWR VPWR sky130_fd_sc_hd__decap_3
XFILLER_79_402 VGND VGND VPWR VPWR sky130_fd_sc_hd__decap_3
XFILLER_4_678 VGND VGND VPWR VPWR sky130_fd_sc_hd__decap_3
XFILLER_106_584 VGND VGND VPWR VPWR sky130_fd_sc_hd__decap_3
XFILLER_106_595 VGND VGND VPWR VPWR sky130_fd_sc_hd__decap_3
XFILLER_3_199 VGND VGND VPWR VPWR sky130_fd_sc_hd__decap_3
XFILLER_121_532 VGND VGND VPWR VPWR sky130_fd_sc_hd__decap_3
XFILLER_121_576 VGND VGND VPWR VPWR sky130_fd_sc_hd__decap_3
XFILLER_94_427 VGND VGND VPWR VPWR sky130_fd_sc_hd__decap_3
XFILLER_59_181 VGND VGND VPWR VPWR sky130_fd_sc_hd__decap_3
XFILLER_75_641 VGND VGND VPWR VPWR sky130_fd_sc_hd__decap_3
XFILLER_47_343 VGND VGND VPWR VPWR sky130_fd_sc_hd__decap_3
XFILLER_35_505 VGND VGND VPWR VPWR sky130_fd_sc_hd__decap_3
XFILLER_75_685 VGND VGND VPWR VPWR sky130_fd_sc_hd__decap_3
XFILLER_74_162 VGND VGND VPWR VPWR sky130_fd_sc_hd__decap_3
XFILLER_90_622 VGND VGND VPWR VPWR sky130_fd_sc_hd__decap_3
XFILLER_62_324 VGND VGND VPWR VPWR sky130_fd_sc_hd__fill_1
XFILLER_90_666 VGND VGND VPWR VPWR sky130_fd_sc_hd__decap_3
XFILLER_62_357 VGND VGND VPWR VPWR sky130_fd_sc_hd__decap_3
XFILLER_90_699 VGND VGND VPWR VPWR sky130_fd_sc_hd__fill_1
XFILLER_31_700 VGND VGND VPWR VPWR sky130_fd_sc_hd__decap_3
XFILLER_15_262 VGND VGND VPWR VPWR sky130_fd_sc_hd__decap_3
XFILLER_95_6 VGND VGND VPWR VPWR sky130_fd_sc_hd__decap_3
XFILLER_43_593 VGND VGND VPWR VPWR sky130_fd_sc_hd__decap_3
XFILLER_30_210 VGND VGND VPWR VPWR sky130_fd_sc_hd__decap_3
XTAP_TAPCELL_ROW_13_430 VGND VPWR sky130_fd_sc_hd__tapvpwrvgnd_1
XTAP_TAPCELL_ROW_13_441 VGND VPWR sky130_fd_sc_hd__tapvpwrvgnd_1
XFILLER_30_265 VGND VGND VPWR VPWR sky130_fd_sc_hd__decap_3
XTAP_TAPCELL_ROW_41_794 VGND VPWR sky130_fd_sc_hd__tapvpwrvgnd_1
X_4540_ _4540_/A _4559_/B VGND VGND VPWR VPWR _7310_/D sky130_fd_sc_hd__and2_2
XTAP_TAPCELL_ROW_96_1513 VGND VPWR sky130_fd_sc_hd__tapvpwrvgnd_1
Xclkbuf_leaf_10_clk clkbuf_leaf_9_clk/A VGND VGND VPWR VPWR _6965_/CLK sky130_fd_sc_hd__clkbuf_16
X_4471_ _7343_/Q _4470_/X _4471_/S VGND VGND VPWR VPWR _7343_/D sky130_fd_sc_hd__mux2_2
X_7190_ _7318_/CLK _7190_/D _6470_/Y VGND VGND VPWR VPWR _7190_/Q sky130_fd_sc_hd__dfrtp_2
XFILLER_98_722 VGND VGND VPWR VPWR sky130_fd_sc_hd__decap_3
XFILLER_112_510 VGND VGND VPWR VPWR sky130_fd_sc_hd__decap_3
X_3353_ _6980_/Q _6979_/Q VGND VGND VPWR VPWR _5668_/A sky130_fd_sc_hd__xor2_2
XFILLER_58_608 VGND VGND VPWR VPWR sky130_fd_sc_hd__decap_3
XFILLER_112_554 VGND VGND VPWR VPWR sky130_fd_sc_hd__decap_3
XFILLER_85_405 VGND VGND VPWR VPWR sky130_fd_sc_hd__fill_2
XFILLER_100_716 VGND VGND VPWR VPWR sky130_fd_sc_hd__decap_3
Xhold1106 _7316_/Q VGND VGND VPWR VPWR _4526_/A0 sky130_fd_sc_hd__dlygate4sd3_1
XFILLER_112_587 VGND VGND VPWR VPWR sky130_fd_sc_hd__fill_1
Xhold1117 _7127_/Q VGND VGND VPWR VPWR _5413_/A0 sky130_fd_sc_hd__dlygate4sd3_1
XFILLER_97_287 VGND VGND VPWR VPWR sky130_fd_sc_hd__decap_3
X_5023_ _5661_/A VGND VGND VPWR VPWR _5023_/Y sky130_fd_sc_hd__inv_2
Xhold1128 _7152_/Q VGND VGND VPWR VPWR _5358_/A0 sky130_fd_sc_hd__dlygate4sd3_1
XFILLER_85_438 VGND VGND VPWR VPWR sky130_fd_sc_hd__decap_3
XFILLER_112_598 VGND VGND VPWR VPWR sky130_fd_sc_hd__decap_3
XFILLER_85_449 VGND VGND VPWR VPWR sky130_fd_sc_hd__fill_1
Xhold1139 _7173_/Q VGND VGND VPWR VPWR _5315_/A0 sky130_fd_sc_hd__dlygate4sd3_1
XFILLER_66_630 VGND VGND VPWR VPWR sky130_fd_sc_hd__decap_3
XFILLER_38_332 VGND VGND VPWR VPWR sky130_fd_sc_hd__fill_2
Xsingle_cycle_cpu_580 VGND VGND VPWR VPWR instruction_out[1] single_cycle_cpu_580/LO
+ sky130_fd_sc_hd__conb_1
XFILLER_66_663 VGND VGND VPWR VPWR sky130_fd_sc_hd__decap_3
XFILLER_38_354 VGND VGND VPWR VPWR sky130_fd_sc_hd__decap_3
XFILLER_81_600 VGND VGND VPWR VPWR sky130_fd_sc_hd__decap_3
XFILLER_53_302 VGND VGND VPWR VPWR sky130_fd_sc_hd__decap_3
XFILLER_66_696 VGND VGND VPWR VPWR sky130_fd_sc_hd__decap_3
X_6974_ _7215_/CLK _6974_/D VGND VGND VPWR VPWR _6974_/Q sky130_fd_sc_hd__dfxtp_2
XFILLER_81_644 VGND VGND VPWR VPWR sky130_fd_sc_hd__decap_3
XFILLER_80_132 VGND VGND VPWR VPWR sky130_fd_sc_hd__decap_3
XTAP_TAPCELL_ROW_105_1631 VGND VPWR sky130_fd_sc_hd__tapvpwrvgnd_1
XFILLER_41_508 VGND VGND VPWR VPWR sky130_fd_sc_hd__decap_3
XFILLER_81_688 VGND VGND VPWR VPWR sky130_fd_sc_hd__decap_3
XFILLER_80_165 VGND VGND VPWR VPWR sky130_fd_sc_hd__decap_3
XFILLER_110_15 VGND VGND VPWR VPWR sky130_fd_sc_hd__decap_3
XFILLER_22_722 VGND VGND VPWR VPWR sky130_fd_sc_hd__decap_3
XFILLER_110_59 VGND VGND VPWR VPWR sky130_fd_sc_hd__decap_3
XPHY_EDGE_ROW_3_Right_3 VGND VGND VPWR VPWR sky130_fd_sc_hd__decap_3
XFILLER_21_243 VGND VGND VPWR VPWR sky130_fd_sc_hd__decap_3
X_4807_ _4807_/A0 _4806_/X _4837_/S VGND VGND VPWR VPWR _7273_/D sky130_fd_sc_hd__mux2_2
XFILLER_21_276 VGND VGND VPWR VPWR sky130_fd_sc_hd__decap_3
XFILLER_21_287 VGND VGND VPWR VPWR sky130_fd_sc_hd__fill_2
X_4738_ _4738_/A _4738_/B VGND VGND VPWR VPWR _7006_/D sky130_fd_sc_hd__nor2_2
XFILLER_119_24 VGND VGND VPWR VPWR sky130_fd_sc_hd__decap_3
XFILLER_119_164 VGND VGND VPWR VPWR sky130_fd_sc_hd__decap_3
XFILLER_119_57 VGND VGND VPWR VPWR sky130_fd_sc_hd__decap_3
X_4669_ _6995_/Q _4690_/B VGND VGND VPWR VPWR _4928_/B sky130_fd_sc_hd__and2_2
XFILLER_107_337 VGND VGND VPWR VPWR sky130_fd_sc_hd__fill_2
X_6408_ _6633_/A VGND VGND VPWR VPWR _6408_/Y sky130_fd_sc_hd__inv_2
Xhold940 _7029_/Q VGND VGND VPWR VPWR hold940/X sky130_fd_sc_hd__dlygate4sd3_1
XTAP_TAPCELL_ROW_116_1771 VGND VPWR sky130_fd_sc_hd__tapvpwrvgnd_1
X_7388_ _7401_/CLK _7388_/D _6668_/Y VGND VGND VPWR VPWR _7388_/Q sky130_fd_sc_hd__dfrtp_2
XFILLER_89_700 VGND VGND VPWR VPWR sky130_fd_sc_hd__decap_3
XFILLER_122_307 VGND VGND VPWR VPWR sky130_fd_sc_hd__fill_1
Xhold951 _7053_/Q VGND VGND VPWR VPWR hold951/X sky130_fd_sc_hd__dlygate4sd3_1
Xhold962 _7035_/Q VGND VGND VPWR VPWR hold962/X sky130_fd_sc_hd__dlygate4sd3_1
Xhold973 _7034_/Q VGND VGND VPWR VPWR _5587_/A sky130_fd_sc_hd__dlygate4sd3_1
XFILLER_1_626 VGND VGND VPWR VPWR sky130_fd_sc_hd__decap_3
X_6339_ _6660_/A VGND VGND VPWR VPWR _6339_/Y sky130_fd_sc_hd__inv_2
Xhold984 _7018_/Q VGND VGND VPWR VPWR _5619_/A sky130_fd_sc_hd__dlygate4sd3_1
Xhold995 _7274_/Q VGND VGND VPWR VPWR hold995/X sky130_fd_sc_hd__dlygate4sd3_1
XFILLER_88_232 VGND VGND VPWR VPWR sky130_fd_sc_hd__decap_3
XFILLER_1_659 VGND VGND VPWR VPWR sky130_fd_sc_hd__decap_3
XFILLER_103_576 VGND VGND VPWR VPWR sky130_fd_sc_hd__decap_3
XFILLER_76_416 VGND VGND VPWR VPWR sky130_fd_sc_hd__fill_1
XFILLER_76_427 VGND VGND VPWR VPWR sky130_fd_sc_hd__fill_2
XFILLER_48_129 VGND VGND VPWR VPWR sky130_fd_sc_hd__fill_2
XFILLER_29_310 VGND VGND VPWR VPWR sky130_fd_sc_hd__fill_1
XFILLER_28_32 VGND VGND VPWR VPWR sky130_fd_sc_hd__decap_3
XFILLER_57_641 VGND VGND VPWR VPWR sky130_fd_sc_hd__decap_3
XFILLER_29_354 VGND VGND VPWR VPWR sky130_fd_sc_hd__decap_3
XFILLER_17_505 VGND VGND VPWR VPWR sky130_fd_sc_hd__fill_1
XFILLER_57_685 VGND VGND VPWR VPWR sky130_fd_sc_hd__decap_3
XFILLER_72_622 VGND VGND VPWR VPWR sky130_fd_sc_hd__decap_3
XFILLER_56_173 VGND VGND VPWR VPWR sky130_fd_sc_hd__fill_2
XTAP_TAPCELL_ROW_67_1136 VGND VPWR sky130_fd_sc_hd__tapvpwrvgnd_1
XFILLER_44_346 VGND VGND VPWR VPWR sky130_fd_sc_hd__fill_2
XFILLER_72_666 VGND VGND VPWR VPWR sky130_fd_sc_hd__decap_3
XFILLER_44_357 VGND VGND VPWR VPWR sky130_fd_sc_hd__fill_1
XFILLER_71_154 VGND VGND VPWR VPWR sky130_fd_sc_hd__decap_3
XFILLER_44_368 VGND VGND VPWR VPWR sky130_fd_sc_hd__decap_3
XFILLER_44_42 VGND VGND VPWR VPWR sky130_fd_sc_hd__decap_3
XFILLER_32_519 VGND VGND VPWR VPWR sky130_fd_sc_hd__decap_3
XFILLER_13_700 VGND VGND VPWR VPWR sky130_fd_sc_hd__decap_3
XFILLER_72_699 VGND VGND VPWR VPWR sky130_fd_sc_hd__fill_1
XTAP_TAPCELL_ROW_80_1303 VGND VPWR sky130_fd_sc_hd__tapvpwrvgnd_1
XFILLER_25_582 VGND VGND VPWR VPWR sky130_fd_sc_hd__decap_3
XFILLER_71_198 VGND VGND VPWR VPWR sky130_fd_sc_hd__decap_3
XFILLER_9_715 VGND VGND VPWR VPWR sky130_fd_sc_hd__decap_3
XFILLER_8_225 VGND VGND VPWR VPWR sky130_fd_sc_hd__fill_2
XFILLER_12_276 VGND VGND VPWR VPWR sky130_fd_sc_hd__decap_3
XTAP_TAPCELL_ROW_10_400 VGND VPWR sky130_fd_sc_hd__tapvpwrvgnd_1
XFILLER_60_85 VGND VGND VPWR VPWR sky130_fd_sc_hd__decap_3
XTAP_TAPCELL_ROW_78_1276 VGND VPWR sky130_fd_sc_hd__tapvpwrvgnd_1
XFILLER_99_508 VGND VGND VPWR VPWR sky130_fd_sc_hd__decap_3
XTAP_TAPCELL_ROW_78_1287 VGND VPWR sky130_fd_sc_hd__tapvpwrvgnd_1
XTAP_TAPCELL_ROW_91_1454 VGND VPWR sky130_fd_sc_hd__tapvpwrvgnd_1
XFILLER_79_232 VGND VGND VPWR VPWR sky130_fd_sc_hd__decap_3
XFILLER_69_94 VGND VGND VPWR VPWR sky130_fd_sc_hd__fill_1
XFILLER_95_703 VGND VGND VPWR VPWR sky130_fd_sc_hd__decap_3
XFILLER_121_340 VGND VGND VPWR VPWR sky130_fd_sc_hd__fill_1
XPHY_EDGE_ROW_105_Left_229 VGND VGND VPWR VPWR sky130_fd_sc_hd__decap_3
XFILLER_79_265 VGND VGND VPWR VPWR sky130_fd_sc_hd__decap_3
XFILLER_79_276 VGND VGND VPWR VPWR sky130_fd_sc_hd__decap_3
XFILLER_94_224 VGND VGND VPWR VPWR sky130_fd_sc_hd__decap_3
XFILLER_79_298 VGND VGND VPWR VPWR sky130_fd_sc_hd__fill_2
XFILLER_0_681 VGND VGND VPWR VPWR sky130_fd_sc_hd__decap_3
XFILLER_67_449 VGND VGND VPWR VPWR sky130_fd_sc_hd__decap_3
XFILLER_48_630 VGND VGND VPWR VPWR sky130_fd_sc_hd__decap_3
XFILLER_85_60 VGND VGND VPWR VPWR sky130_fd_sc_hd__decap_3
XFILLER_94_268 VGND VGND VPWR VPWR sky130_fd_sc_hd__fill_2
XFILLER_48_663 VGND VGND VPWR VPWR sky130_fd_sc_hd__decap_3
XFILLER_85_82 VGND VGND VPWR VPWR sky130_fd_sc_hd__decap_3
XFILLER_75_460 VGND VGND VPWR VPWR sky130_fd_sc_hd__decap_3
XTAP_TAPCELL_ROW_18_500 VGND VPWR sky130_fd_sc_hd__tapvpwrvgnd_1
XFILLER_48_696 VGND VGND VPWR VPWR sky130_fd_sc_hd__decap_3
XFILLER_63_644 VGND VGND VPWR VPWR sky130_fd_sc_hd__decap_3
XTAP_TAPCELL_ROW_46_864 VGND VPWR sky130_fd_sc_hd__tapvpwrvgnd_1
XFILLER_62_154 VGND VGND VPWR VPWR sky130_fd_sc_hd__fill_2
XFILLER_63_688 VGND VGND VPWR VPWR sky130_fd_sc_hd__decap_3
XFILLER_50_327 VGND VGND VPWR VPWR sky130_fd_sc_hd__decap_3
XFILLER_16_582 VGND VGND VPWR VPWR sky130_fd_sc_hd__decap_3
X_5710_ _7361_/Q hold925/X _5737_/S VGND VGND VPWR VPWR _6705_/D sky130_fd_sc_hd__mux2_2
XPHY_EDGE_ROW_114_Left_238 VGND VGND VPWR VPWR sky130_fd_sc_hd__decap_3
X_6690_ _7378_/CLK _6690_/D VGND VGND VPWR VPWR _6690_/Q sky130_fd_sc_hd__dfxtp_2
XFILLER_31_530 VGND VGND VPWR VPWR sky130_fd_sc_hd__fill_1
XFILLER_31_552 VGND VGND VPWR VPWR sky130_fd_sc_hd__fill_2
X_5641_ _5641_/A VGND VGND VPWR VPWR _5641_/Y sky130_fd_sc_hd__inv_2
XFILLER_31_585 VGND VGND VPWR VPWR sky130_fd_sc_hd__decap_3
XTAP_TAPCELL_ROW_100_1561 VGND VPWR sky130_fd_sc_hd__tapvpwrvgnd_1
XTAP_TAPCELL_ROW_100_1572 VGND VPWR sky130_fd_sc_hd__tapvpwrvgnd_1
X_5572_ hold953/X _5587_/B _4961_/C VGND VGND VPWR VPWR _7045_/D sky130_fd_sc_hd__a21o_2
X_7311_ _7345_/CLK _7311_/D _6591_/Y VGND VGND VPWR VPWR _7311_/Q sky130_fd_sc_hd__dfrtp_2
XFILLER_117_635 VGND VGND VPWR VPWR sky130_fd_sc_hd__decap_3
XFILLER_117_668 VGND VGND VPWR VPWR sky130_fd_sc_hd__decap_3
X_7242_ _7404_/CLK _7242_/D _6522_/Y VGND VGND VPWR VPWR _7242_/Q sky130_fd_sc_hd__dfrtp_2
XFILLER_117_679 VGND VGND VPWR VPWR sky130_fd_sc_hd__decap_3
X_4454_ _4761_/B _4761_/C _4069_/Y _4762_/B VGND VGND VPWR VPWR _4454_/X sky130_fd_sc_hd__a211o_2
XFILLER_104_318 VGND VGND VPWR VPWR sky130_fd_sc_hd__decap_3
X_3405_ _5129_/A _6983_/Q _3340_/C _4667_/B VGND VGND VPWR VPWR _3409_/D sky130_fd_sc_hd__o31a_2
X_7173_ _7368_/CLK _7173_/D _6453_/Y VGND VGND VPWR VPWR _7173_/Q sky130_fd_sc_hd__dfrtp_2
XPHY_EDGE_ROW_123_Left_247 VGND VGND VPWR VPWR sky130_fd_sc_hd__decap_3
X_4385_ _7337_/Q _3945_/S _4428_/B1 _7145_/Q VGND VGND VPWR VPWR _4385_/X sky130_fd_sc_hd__a22o_2
XFILLER_98_541 VGND VGND VPWR VPWR sky130_fd_sc_hd__decap_3
XFILLER_98_574 VGND VGND VPWR VPWR sky130_fd_sc_hd__decap_3
XFILLER_86_725 VGND VGND VPWR VPWR sky130_fd_sc_hd__decap_3
XFILLER_112_362 VGND VGND VPWR VPWR sky130_fd_sc_hd__fill_2
XFILLER_105_15 VGND VGND VPWR VPWR sky130_fd_sc_hd__decap_3
XFILLER_100_513 VGND VGND VPWR VPWR sky130_fd_sc_hd__fill_2
XFILLER_85_213 VGND VGND VPWR VPWR sky130_fd_sc_hd__decap_3
XFILLER_58_427 VGND VGND VPWR VPWR sky130_fd_sc_hd__decap_3
XFILLER_112_384 VGND VGND VPWR VPWR sky130_fd_sc_hd__decap_3
XFILLER_39_641 VGND VGND VPWR VPWR sky130_fd_sc_hd__decap_3
X_5006_ _5072_/A _4626_/X _5003_/A _5033_/B2 VGND VGND VPWR VPWR _5006_/X sky130_fd_sc_hd__a22o_2
XFILLER_85_268 VGND VGND VPWR VPWR sky130_fd_sc_hd__decap_3
XFILLER_100_568 VGND VGND VPWR VPWR sky130_fd_sc_hd__decap_3
XFILLER_39_685 VGND VGND VPWR VPWR sky130_fd_sc_hd__decap_3
XFILLER_54_622 VGND VGND VPWR VPWR sky130_fd_sc_hd__decap_3
XFILLER_93_290 VGND VGND VPWR VPWR sky130_fd_sc_hd__decap_3
XFILLER_38_195 VGND VGND VPWR VPWR sky130_fd_sc_hd__fill_1
XFILLER_54_666 VGND VGND VPWR VPWR sky130_fd_sc_hd__decap_3
XFILLER_26_357 VGND VGND VPWR VPWR sky130_fd_sc_hd__decap_3
XFILLER_121_36 VGND VGND VPWR VPWR sky130_fd_sc_hd__decap_3
XFILLER_26_368 VGND VGND VPWR VPWR sky130_fd_sc_hd__decap_3
X_6957_ clkload4/A _6957_/D VGND VGND VPWR VPWR _6957_/Q sky130_fd_sc_hd__dfxtp_2
XFILLER_81_18 VGND VGND VPWR VPWR sky130_fd_sc_hd__fill_1
XFILLER_121_69 VGND VGND VPWR VPWR sky130_fd_sc_hd__decap_3
XFILLER_54_699 VGND VGND VPWR VPWR sky130_fd_sc_hd__fill_1
XFILLER_53_187 VGND VGND VPWR VPWR sky130_fd_sc_hd__decap_3
X_6888_ clkload9/A _6888_/D VGND VGND VPWR VPWR _6888_/Q sky130_fd_sc_hd__dfxtp_2
XTAP_TAPCELL_ROW_62_1077 VGND VPWR sky130_fd_sc_hd__tapvpwrvgnd_1
XFILLER_10_725 VGND VGND VPWR VPWR sky130_fd_sc_hd__decap_3
XFILLER_14_78 VGND VGND VPWR VPWR sky130_fd_sc_hd__fill_1
XTAP_TAPCELL_ROW_118_1800 VGND VPWR sky130_fd_sc_hd__tapvpwrvgnd_1
XFILLER_6_707 VGND VGND VPWR VPWR sky130_fd_sc_hd__decap_3
XFILLER_108_613 VGND VGND VPWR VPWR sky130_fd_sc_hd__decap_3
XFILLER_107_101 VGND VGND VPWR VPWR sky130_fd_sc_hd__fill_2
XFILLER_108_657 VGND VGND VPWR VPWR sky130_fd_sc_hd__decap_3
XFILLER_107_134 VGND VGND VPWR VPWR sky130_fd_sc_hd__decap_3
XFILLER_123_605 VGND VGND VPWR VPWR sky130_fd_sc_hd__decap_3
XFILLER_107_167 VGND VGND VPWR VPWR sky130_fd_sc_hd__fill_1
XFILLER_30_88 VGND VGND VPWR VPWR sky130_fd_sc_hd__decap_3
XFILLER_107_178 VGND VGND VPWR VPWR sky130_fd_sc_hd__decap_3
XFILLER_123_638 VGND VGND VPWR VPWR sky130_fd_sc_hd__decap_3
XFILLER_116_690 VGND VGND VPWR VPWR sky130_fd_sc_hd__decap_3
Xhold770 _6926_/Q VGND VGND VPWR VPWR _6926_/D sky130_fd_sc_hd__dlygate4sd3_1
Xhold781 _6954_/Q VGND VGND VPWR VPWR _6954_/D sky130_fd_sc_hd__dlygate4sd3_1
XFILLER_89_541 VGND VGND VPWR VPWR sky130_fd_sc_hd__decap_3
Xhold792 _6839_/Q VGND VGND VPWR VPWR _6839_/D sky130_fd_sc_hd__dlygate4sd3_1
XFILLER_77_703 VGND VGND VPWR VPWR sky130_fd_sc_hd__decap_3
XFILLER_39_20 VGND VGND VPWR VPWR sky130_fd_sc_hd__fill_1
XFILLER_103_340 VGND VGND VPWR VPWR sky130_fd_sc_hd__decap_3
XFILLER_89_585 VGND VGND VPWR VPWR sky130_fd_sc_hd__decap_3
XFILLER_76_213 VGND VGND VPWR VPWR sky130_fd_sc_hd__decap_3
XFILLER_49_449 VGND VGND VPWR VPWR sky130_fd_sc_hd__decap_3
XFILLER_39_75 VGND VGND VPWR VPWR sky130_fd_sc_hd__fill_2
XFILLER_39_86 VGND VGND VPWR VPWR sky130_fd_sc_hd__fill_2
XFILLER_76_246 VGND VGND VPWR VPWR sky130_fd_sc_hd__decap_3
XFILLER_76_268 VGND VGND VPWR VPWR sky130_fd_sc_hd__decap_3
XFILLER_92_728 VGND VGND VPWR VPWR sky130_fd_sc_hd__decap_3
XFILLER_64_419 VGND VGND VPWR VPWR sky130_fd_sc_hd__fill_1
XFILLER_76_279 VGND VGND VPWR VPWR sky130_fd_sc_hd__decap_3
XFILLER_91_216 VGND VGND VPWR VPWR sky130_fd_sc_hd__decap_3
XFILLER_91_249 VGND VGND VPWR VPWR sky130_fd_sc_hd__decap_3
XFILLER_84_290 VGND VGND VPWR VPWR sky130_fd_sc_hd__decap_3
XFILLER_45_644 VGND VGND VPWR VPWR sky130_fd_sc_hd__decap_3
XFILLER_29_195 VGND VGND VPWR VPWR sky130_fd_sc_hd__decap_3
XFILLER_17_346 VGND VGND VPWR VPWR sky130_fd_sc_hd__decap_3
XFILLER_55_63 VGND VGND VPWR VPWR sky130_fd_sc_hd__fill_2
XFILLER_45_688 VGND VGND VPWR VPWR sky130_fd_sc_hd__decap_3
XFILLER_17_379 VGND VGND VPWR VPWR sky130_fd_sc_hd__decap_3
XFILLER_72_485 VGND VGND VPWR VPWR sky130_fd_sc_hd__decap_3
XFILLER_60_625 VGND VGND VPWR VPWR sky130_fd_sc_hd__decap_3
XTAP_TAPCELL_ROW_43_823 VGND VPWR sky130_fd_sc_hd__tapvpwrvgnd_1
XFILLER_32_327 VGND VGND VPWR VPWR sky130_fd_sc_hd__fill_2
XFILLER_60_669 VGND VGND VPWR VPWR sky130_fd_sc_hd__decap_3
XFILLER_40_360 VGND VGND VPWR VPWR sky130_fd_sc_hd__decap_3
XFILLER_13_585 VGND VGND VPWR VPWR sky130_fd_sc_hd__decap_3
XFILLER_40_371 VGND VGND VPWR VPWR sky130_fd_sc_hd__decap_3
XFILLER_9_556 VGND VGND VPWR VPWR sky130_fd_sc_hd__decap_3
XFILLER_9_567 VGND VGND VPWR VPWR sky130_fd_sc_hd__decap_3
XFILLER_114_616 VGND VGND VPWR VPWR sky130_fd_sc_hd__decap_3
X_4170_ _4203_/A _4203_/B _4202_/A VGND VGND VPWR VPWR _4938_/B sky130_fd_sc_hd__and3_2
XFILLER_122_660 VGND VGND VPWR VPWR sky130_fd_sc_hd__decap_3
XFILLER_68_725 VGND VGND VPWR VPWR sky130_fd_sc_hd__decap_3
XFILLER_122_693 VGND VGND VPWR VPWR sky130_fd_sc_hd__decap_3
XFILLER_95_533 VGND VGND VPWR VPWR sky130_fd_sc_hd__decap_3
XFILLER_83_706 VGND VGND VPWR VPWR sky130_fd_sc_hd__decap_3
XFILLER_55_408 VGND VGND VPWR VPWR sky130_fd_sc_hd__decap_3
XFILLER_95_588 VGND VGND VPWR VPWR sky130_fd_sc_hd__decap_3
XFILLER_36_622 VGND VGND VPWR VPWR sky130_fd_sc_hd__decap_3
XFILLER_48_493 VGND VGND VPWR VPWR sky130_fd_sc_hd__decap_3
XFILLER_35_110 VGND VGND VPWR VPWR sky130_fd_sc_hd__fill_2
XFILLER_63_452 VGND VGND VPWR VPWR sky130_fd_sc_hd__decap_3
XFILLER_36_666 VGND VGND VPWR VPWR sky130_fd_sc_hd__decap_3
X_6811_ clkload8/A _6811_/D VGND VGND VPWR VPWR _6811_/Q sky130_fd_sc_hd__dfxtp_2
Xplace430 _3977_/S VGND VGND VPWR VPWR _3996_/S sky130_fd_sc_hd__buf_2
XFILLER_23_305 VGND VGND VPWR VPWR sky130_fd_sc_hd__decap_3
Xplace441 _4467_/Y VGND VGND VPWR VPWR _5581_/S sky130_fd_sc_hd__buf_2
XFILLER_36_699 VGND VGND VPWR VPWR sky130_fd_sc_hd__fill_1
Xplace452 _6982_/Q VGND VGND VPWR VPWR _3340_/A sky130_fd_sc_hd__buf_2
XFILLER_63_485 VGND VGND VPWR VPWR sky130_fd_sc_hd__decap_3
XFILLER_51_647 VGND VGND VPWR VPWR sky130_fd_sc_hd__decap_3
X_6742_ _6978_/CLK _6742_/D VGND VGND VPWR VPWR _6742_/Q sky130_fd_sc_hd__dfxtp_2
XFILLER_23_349 VGND VGND VPWR VPWR sky130_fd_sc_hd__fill_2
X_3954_ _7363_/Q _4497_/A0 _3956_/S VGND VGND VPWR VPWR _7363_/D sky130_fd_sc_hd__mux2_2
XFILLER_50_157 VGND VGND VPWR VPWR sky130_fd_sc_hd__fill_1
X_6673_ _6674_/A VGND VGND VPWR VPWR _6673_/Y sky130_fd_sc_hd__inv_2
X_3885_ _3746_/X _3882_/X _3884_/X _3725_/X VGND VGND VPWR VPWR _3885_/X sky130_fd_sc_hd__a22o_2
XFILLER_31_371 VGND VGND VPWR VPWR sky130_fd_sc_hd__decap_3
XTAP_TAPCELL_ROW_21_539 VGND VPWR sky130_fd_sc_hd__tapvpwrvgnd_1
X_5624_ _5624_/A _5633_/B VGND VGND VPWR VPWR _7016_/D sky130_fd_sc_hd__or2_2
XFILLER_31_393 VGND VGND VPWR VPWR sky130_fd_sc_hd__decap_3
XFILLER_2_209 VGND VGND VPWR VPWR sky130_fd_sc_hd__decap_3
XFILLER_117_476 VGND VGND VPWR VPWR sky130_fd_sc_hd__decap_3
XFILLER_105_638 VGND VGND VPWR VPWR sky130_fd_sc_hd__decap_3
XTAP_TAPCELL_ROW_113_1730 VGND VPWR sky130_fd_sc_hd__tapvpwrvgnd_1
X_7225_ _7356_/CLK _7225_/D _6505_/Y VGND VGND VPWR VPWR _7225_/Q sky130_fd_sc_hd__dfrtp_2
XTAP_TAPCELL_ROW_113_1741 VGND VPWR sky130_fd_sc_hd__tapvpwrvgnd_1
X_4437_ _7022_/Q _4437_/A2 _4437_/B1 _7399_/Q _4436_/X VGND VGND VPWR VPWR _4437_/X
+ sky130_fd_sc_hd__a221o_2
XFILLER_116_14 VGND VGND VPWR VPWR sky130_fd_sc_hd__decap_3
XFILLER_104_137 VGND VGND VPWR VPWR sky130_fd_sc_hd__decap_3
XFILLER_59_703 VGND VGND VPWR VPWR sky130_fd_sc_hd__decap_3
XFILLER_120_619 VGND VGND VPWR VPWR sky130_fd_sc_hd__decap_3
XFILLER_116_47 VGND VGND VPWR VPWR sky130_fd_sc_hd__decap_3
X_7156_ _7279_/CLK _7156_/D _6436_/Y VGND VGND VPWR VPWR _7156_/Q sky130_fd_sc_hd__dfrtp_2
X_4368_ _5073_/A _4366_/X _5054_/A VGND VGND VPWR VPWR _4369_/B sky130_fd_sc_hd__a21oi_2
XFILLER_98_360 VGND VGND VPWR VPWR sky130_fd_sc_hd__decap_3
XFILLER_113_671 VGND VGND VPWR VPWR sky130_fd_sc_hd__fill_1
XFILLER_58_213 VGND VGND VPWR VPWR sky130_fd_sc_hd__fill_2
XFILLER_113_682 VGND VGND VPWR VPWR sky130_fd_sc_hd__decap_3
X_3319_ _3378_/A _5646_/A _5647_/A _5647_/B VGND VGND VPWR VPWR _3319_/X sky130_fd_sc_hd__and4b_4
XFILLER_86_544 VGND VGND VPWR VPWR sky130_fd_sc_hd__decap_3
X_7087_ _7279_/CLK _7087_/D _6367_/Y VGND VGND VPWR VPWR _7087_/Q sky130_fd_sc_hd__dfstp_2
X_4299_ _3620_/A _4292_/X _4298_/X VGND VGND VPWR VPWR _5100_/B sky130_fd_sc_hd__a21o_2
XFILLER_58_246 VGND VGND VPWR VPWR sky130_fd_sc_hd__decap_3
XFILLER_58_257 VGND VGND VPWR VPWR sky130_fd_sc_hd__decap_3
XFILLER_100_343 VGND VGND VPWR VPWR sky130_fd_sc_hd__decap_3
XFILLER_86_577 VGND VGND VPWR VPWR sky130_fd_sc_hd__decap_3
XFILLER_74_728 VGND VGND VPWR VPWR sky130_fd_sc_hd__decap_3
XFILLER_58_279 VGND VGND VPWR VPWR sky130_fd_sc_hd__decap_3
XFILLER_100_365 VGND VGND VPWR VPWR sky130_fd_sc_hd__decap_3
XFILLER_27_611 VGND VGND VPWR VPWR sky130_fd_sc_hd__decap_3
XTAP_TAPCELL_ROW_29_639 VGND VPWR sky130_fd_sc_hd__tapvpwrvgnd_1
XFILLER_73_249 VGND VGND VPWR VPWR sky130_fd_sc_hd__decap_3
XFILLER_54_430 VGND VGND VPWR VPWR sky130_fd_sc_hd__decap_3
XFILLER_27_644 VGND VGND VPWR VPWR sky130_fd_sc_hd__decap_3
XFILLER_54_452 VGND VGND VPWR VPWR sky130_fd_sc_hd__fill_1
XTAP_TAPCELL_ROW_1_275 VGND VPWR sky130_fd_sc_hd__tapvpwrvgnd_1
XFILLER_27_688 VGND VGND VPWR VPWR sky130_fd_sc_hd__decap_3
XTAP_TAPCELL_ROW_1_286 VGND VPWR sky130_fd_sc_hd__tapvpwrvgnd_1
XFILLER_54_474 VGND VGND VPWR VPWR sky130_fd_sc_hd__fill_2
XFILLER_42_625 VGND VGND VPWR VPWR sky130_fd_sc_hd__decap_3
XFILLER_41_102 VGND VGND VPWR VPWR sky130_fd_sc_hd__fill_1
XFILLER_41_113 VGND VGND VPWR VPWR sky130_fd_sc_hd__decap_3
XFILLER_14_349 VGND VGND VPWR VPWR sky130_fd_sc_hd__decap_3
XFILLER_42_669 VGND VGND VPWR VPWR sky130_fd_sc_hd__decap_3
XFILLER_22_393 VGND VGND VPWR VPWR sky130_fd_sc_hd__fill_1
XFILLER_10_533 VGND VGND VPWR VPWR sky130_fd_sc_hd__decap_3
XFILLER_10_566 VGND VGND VPWR VPWR sky130_fd_sc_hd__decap_3
XFILLER_108_421 VGND VGND VPWR VPWR sky130_fd_sc_hd__decap_3
XFILLER_6_548 VGND VGND VPWR VPWR sky130_fd_sc_hd__decap_3
XFILLER_123_402 VGND VGND VPWR VPWR sky130_fd_sc_hd__decap_3
XTAP_TAPCELL_ROW_75_1246 VGND VPWR sky130_fd_sc_hd__tapvpwrvgnd_1
XFILLER_2_710 VGND VGND VPWR VPWR sky130_fd_sc_hd__decap_3
XFILLER_123_413 VGND VGND VPWR VPWR sky130_fd_sc_hd__decap_3
XFILLER_123_424 VGND VGND VPWR VPWR sky130_fd_sc_hd__decap_3
XFILLER_123_446 VGND VGND VPWR VPWR sky130_fd_sc_hd__fill_2
XFILLER_1_231 VGND VGND VPWR VPWR sky130_fd_sc_hd__decap_3
XTAP_TAPCELL_ROW_9_386 VGND VPWR sky130_fd_sc_hd__tapvpwrvgnd_1
XFILLER_104_660 VGND VGND VPWR VPWR sky130_fd_sc_hd__decap_3
XFILLER_89_360 VGND VGND VPWR VPWR sky130_fd_sc_hd__decap_3
XFILLER_77_500 VGND VGND VPWR VPWR sky130_fd_sc_hd__decap_3
XFILLER_77_511 VGND VGND VPWR VPWR sky130_fd_sc_hd__decap_3
XFILLER_89_382 VGND VGND VPWR VPWR sky130_fd_sc_hd__decap_3
XFILLER_2_15 VGND VGND VPWR VPWR sky130_fd_sc_hd__decap_3
XFILLER_104_693 VGND VGND VPWR VPWR sky130_fd_sc_hd__decap_3
XFILLER_89_393 VGND VGND VPWR VPWR sky130_fd_sc_hd__decap_3
XFILLER_103_181 VGND VGND VPWR VPWR sky130_fd_sc_hd__decap_3
XFILLER_49_246 VGND VGND VPWR VPWR sky130_fd_sc_hd__fill_2
XFILLER_65_706 VGND VGND VPWR VPWR sky130_fd_sc_hd__decap_3
XFILLER_37_419 VGND VGND VPWR VPWR sky130_fd_sc_hd__decap_3
XFILLER_64_227 VGND VGND VPWR VPWR sky130_fd_sc_hd__decap_3
XFILLER_18_622 VGND VGND VPWR VPWR sky130_fd_sc_hd__decap_3
XFILLER_92_547 VGND VGND VPWR VPWR sky130_fd_sc_hd__decap_3
XFILLER_17_110 VGND VGND VPWR VPWR sky130_fd_sc_hd__fill_2
XFILLER_45_430 VGND VGND VPWR VPWR sky130_fd_sc_hd__decap_3
XFILLER_18_666 VGND VGND VPWR VPWR sky130_fd_sc_hd__decap_3
XFILLER_45_452 VGND VGND VPWR VPWR sky130_fd_sc_hd__fill_1
XFILLER_72_260 VGND VGND VPWR VPWR sky130_fd_sc_hd__decap_3
XFILLER_33_614 VGND VGND VPWR VPWR sky130_fd_sc_hd__fill_2
XTAP_TAPCELL_ROW_86_1386 VGND VPWR sky130_fd_sc_hd__tapvpwrvgnd_1
XFILLER_18_699 VGND VGND VPWR VPWR sky130_fd_sc_hd__fill_1
XTAP_TAPCELL_ROW_56_992 VGND VPWR sky130_fd_sc_hd__tapvpwrvgnd_1
XFILLER_82_61 VGND VGND VPWR VPWR sky130_fd_sc_hd__decap_3
XFILLER_33_647 VGND VGND VPWR VPWR sky130_fd_sc_hd__decap_3
XFILLER_82_83 VGND VGND VPWR VPWR sky130_fd_sc_hd__fill_1
XFILLER_82_94 VGND VGND VPWR VPWR sky130_fd_sc_hd__decap_3
XFILLER_60_466 VGND VGND VPWR VPWR sky130_fd_sc_hd__decap_3
XFILLER_60_477 VGND VGND VPWR VPWR sky130_fd_sc_hd__decap_3
XFILLER_13_371 VGND VGND VPWR VPWR sky130_fd_sc_hd__decap_3
XFILLER_41_691 VGND VGND VPWR VPWR sky130_fd_sc_hd__decap_3
XFILLER_13_393 VGND VGND VPWR VPWR sky130_fd_sc_hd__decap_3
X_3670_ _3682_/A _3669_/X _4791_/A1 VGND VGND VPWR VPWR _3670_/X sky130_fd_sc_hd__a21o_2
XFILLER_118_218 VGND VGND VPWR VPWR sky130_fd_sc_hd__decap_3
XFILLER_9_375 VGND VGND VPWR VPWR sky130_fd_sc_hd__decap_3
X_5340_ _5340_/A0 _5079_/X _5340_/S VGND VGND VPWR VPWR _7161_/D sky130_fd_sc_hd__mux2_2
XFILLER_5_570 VGND VGND VPWR VPWR sky130_fd_sc_hd__decap_3
XFILLER_99_157 VGND VGND VPWR VPWR sky130_fd_sc_hd__decap_3
X_7010_ _7371_/CLK _7010_/D _6290_/Y VGND VGND VPWR VPWR _7010_/Q sky130_fd_sc_hd__dfrtp_2
X_4222_ _7356_/Q _4337_/B _4221_/X VGND VGND VPWR VPWR _4222_/X sky130_fd_sc_hd__a21o_2
XFILLER_102_619 VGND VGND VPWR VPWR sky130_fd_sc_hd__decap_3
XFILLER_68_533 VGND VGND VPWR VPWR sky130_fd_sc_hd__fill_1
X_4153_ _7298_/Q _4979_/S _4267_/B1 _7170_/Q _4152_/X VGND VGND VPWR VPWR _4153_/X
+ sky130_fd_sc_hd__a221o_2
XFILLER_110_663 VGND VGND VPWR VPWR sky130_fd_sc_hd__decap_3
XFILLER_56_728 VGND VGND VPWR VPWR sky130_fd_sc_hd__decap_3
X_4084_ _7302_/Q _4497_/S _4083_/X _4429_/C1 VGND VGND VPWR VPWR _4084_/X sky130_fd_sc_hd__a211o_2
XFILLER_110_696 VGND VGND VPWR VPWR sky130_fd_sc_hd__decap_3
XFILLER_95_396 VGND VGND VPWR VPWR sky130_fd_sc_hd__decap_3
XFILLER_71_709 VGND VGND VPWR VPWR sky130_fd_sc_hd__decap_3
XFILLER_36_430 VGND VGND VPWR VPWR sky130_fd_sc_hd__decap_3
XTAP_TAPCELL_ROW_26_609 VGND VPWR sky130_fd_sc_hd__tapvpwrvgnd_1
XFILLER_70_208 VGND VGND VPWR VPWR sky130_fd_sc_hd__fill_1
XFILLER_102_27 VGND VGND VPWR VPWR sky130_fd_sc_hd__fill_1
XFILLER_24_625 VGND VGND VPWR VPWR sky130_fd_sc_hd__decap_3
XFILLER_51_411 VGND VGND VPWR VPWR sky130_fd_sc_hd__decap_3
XFILLER_91_591 VGND VGND VPWR VPWR sky130_fd_sc_hd__decap_3
XFILLER_23_113 VGND VGND VPWR VPWR sky130_fd_sc_hd__fill_2
Xplace271 _3923_/A1 VGND VGND VPWR VPWR _3682_/A sky130_fd_sc_hd__buf_2
XFILLER_24_669 VGND VGND VPWR VPWR sky130_fd_sc_hd__decap_3
X_4986_ _5003_/A _5003_/B _4626_/X VGND VGND VPWR VPWR _4987_/B sky130_fd_sc_hd__a21oi_2
Xplace282 _3851_/A2 VGND VGND VPWR VPWR _3892_/A2 sky130_fd_sc_hd__buf_2
XFILLER_51_455 VGND VGND VPWR VPWR sky130_fd_sc_hd__decap_3
XFILLER_23_146 VGND VGND VPWR VPWR sky130_fd_sc_hd__decap_3
Xplace293 _3884_/B1 VGND VGND VPWR VPWR _3917_/A2 sky130_fd_sc_hd__buf_2
XFILLER_11_319 VGND VGND VPWR VPWR sky130_fd_sc_hd__decap_3
X_3937_ _7371_/Q _4480_/A0 _3945_/S VGND VGND VPWR VPWR _7371_/D sky130_fd_sc_hd__mux2_2
X_6725_ _6967_/CLK _6725_/D VGND VGND VPWR VPWR _6725_/Q sky130_fd_sc_hd__dfxtp_2
X_6656_ _6658_/A VGND VGND VPWR VPWR _6656_/Y sky130_fd_sc_hd__inv_2
X_3868_ _3868_/A1 _5104_/A _3867_/X VGND VGND VPWR VPWR _7384_/D sky130_fd_sc_hd__a21o_2
X_5607_ _5607_/A _5634_/B VGND VGND VPWR VPWR _7024_/D sky130_fd_sc_hd__and2_2
X_6587_ _6588_/A VGND VGND VPWR VPWR _6587_/Y sky130_fd_sc_hd__inv_2
X_3799_ _6909_/Q _3892_/A2 _3878_/A2 _6853_/Q VGND VGND VPWR VPWR _3799_/X sky130_fd_sc_hd__a22o_2
XFILLER_117_240 VGND VGND VPWR VPWR sky130_fd_sc_hd__decap_3
XFILLER_11_57 VGND VGND VPWR VPWR sky130_fd_sc_hd__fill_1
XFILLER_3_529 VGND VGND VPWR VPWR sky130_fd_sc_hd__decap_3
XFILLER_11_79 VGND VGND VPWR VPWR sky130_fd_sc_hd__decap_3
XFILLER_117_284 VGND VGND VPWR VPWR sky130_fd_sc_hd__decap_3
X_7208_ _7368_/CLK _7208_/D _6488_/Y VGND VGND VPWR VPWR _7208_/Q sky130_fd_sc_hd__dfrtp_2
XFILLER_99_691 VGND VGND VPWR VPWR sky130_fd_sc_hd__decap_3
XTAP_TAPCELL_ROW_6_345 VGND VPWR sky130_fd_sc_hd__tapvpwrvgnd_1
X_7139_ _7365_/CLK _7139_/D _6419_/Y VGND VGND VPWR VPWR _7139_/Q sky130_fd_sc_hd__dfrtp_2
XFILLER_101_641 VGND VGND VPWR VPWR sky130_fd_sc_hd__decap_3
XTAP_TAPCELL_ROW_70_1176 VGND VPWR sky130_fd_sc_hd__tapvpwrvgnd_1
XFILLER_47_706 VGND VGND VPWR VPWR sky130_fd_sc_hd__decap_3
XFILLER_19_408 VGND VGND VPWR VPWR sky130_fd_sc_hd__decap_3
XFILLER_101_685 VGND VGND VPWR VPWR sky130_fd_sc_hd__decap_3
XFILLER_86_385 VGND VGND VPWR VPWR sky130_fd_sc_hd__decap_3
XFILLER_46_216 VGND VGND VPWR VPWR sky130_fd_sc_hd__decap_3
XFILLER_100_162 VGND VGND VPWR VPWR sky130_fd_sc_hd__decap_3
XFILLER_74_547 VGND VGND VPWR VPWR sky130_fd_sc_hd__fill_2
XFILLER_27_452 VGND VGND VPWR VPWR sky130_fd_sc_hd__fill_1
XFILLER_15_603 VGND VGND VPWR VPWR sky130_fd_sc_hd__decap_3
XFILLER_82_580 VGND VGND VPWR VPWR sky130_fd_sc_hd__decap_3
XFILLER_42_411 VGND VGND VPWR VPWR sky130_fd_sc_hd__decap_3
XFILLER_70_731 VGND VGND VPWR VPWR sky130_fd_sc_hd__decap_3
XFILLER_15_647 VGND VGND VPWR VPWR sky130_fd_sc_hd__decap_3
XFILLER_54_293 VGND VGND VPWR VPWR sky130_fd_sc_hd__fill_2
XTAP_TAPCELL_ROW_53_951 VGND VPWR sky130_fd_sc_hd__tapvpwrvgnd_1
XTAP_TAPCELL_ROW_53_962 VGND VPWR sky130_fd_sc_hd__tapvpwrvgnd_1
XFILLER_42_477 VGND VGND VPWR VPWR sky130_fd_sc_hd__decap_3
XFILLER_30_628 VGND VGND VPWR VPWR sky130_fd_sc_hd__decap_3
XFILLER_23_691 VGND VGND VPWR VPWR sky130_fd_sc_hd__decap_3
XFILLER_6_312 VGND VGND VPWR VPWR sky130_fd_sc_hd__decap_3
XFILLER_6_378 VGND VGND VPWR VPWR sky130_fd_sc_hd__fill_1
XFILLER_97_606 VGND VGND VPWR VPWR sky130_fd_sc_hd__decap_3
XFILLER_97_617 VGND VGND VPWR VPWR sky130_fd_sc_hd__decap_3
XFILLER_2_551 VGND VGND VPWR VPWR sky130_fd_sc_hd__decap_3
XFILLER_111_427 VGND VGND VPWR VPWR sky130_fd_sc_hd__decap_3
XFILLER_2_584 VGND VGND VPWR VPWR sky130_fd_sc_hd__decap_3
XFILLER_117_90 VGND VGND VPWR VPWR sky130_fd_sc_hd__decap_3
XFILLER_2_595 VGND VGND VPWR VPWR sky130_fd_sc_hd__decap_3
XFILLER_89_190 VGND VGND VPWR VPWR sky130_fd_sc_hd__decap_3
XFILLER_38_728 VGND VGND VPWR VPWR sky130_fd_sc_hd__decap_3
XTAP_TAPCELL_ROW_88_1415 VGND VPWR sky130_fd_sc_hd__tapvpwrvgnd_1
XFILLER_65_514 VGND VGND VPWR VPWR sky130_fd_sc_hd__decap_3
XFILLER_77_396 VGND VGND VPWR VPWR sky130_fd_sc_hd__decap_3
XFILLER_65_536 VGND VGND VPWR VPWR sky130_fd_sc_hd__decap_3
XFILLER_92_322 VGND VGND VPWR VPWR sky130_fd_sc_hd__decap_3
XFILLER_37_249 VGND VGND VPWR VPWR sky130_fd_sc_hd__decap_3
XFILLER_18_430 VGND VGND VPWR VPWR sky130_fd_sc_hd__decap_3
XFILLER_92_355 VGND VGND VPWR VPWR sky130_fd_sc_hd__decap_3
XFILLER_53_709 VGND VGND VPWR VPWR sky130_fd_sc_hd__decap_3
XFILLER_52_208 VGND VGND VPWR VPWR sky130_fd_sc_hd__fill_1
XFILLER_45_271 VGND VGND VPWR VPWR sky130_fd_sc_hd__decap_3
XFILLER_18_496 VGND VGND VPWR VPWR sky130_fd_sc_hd__decap_3
XFILLER_45_293 VGND VGND VPWR VPWR sky130_fd_sc_hd__decap_3
X_4840_ _4903_/B _4903_/C _4903_/A VGND VGND VPWR VPWR _4888_/B sky130_fd_sc_hd__a21oi_2
XFILLER_33_444 VGND VGND VPWR VPWR sky130_fd_sc_hd__decap_3
XFILLER_21_617 VGND VGND VPWR VPWR sky130_fd_sc_hd__decap_3
XFILLER_60_274 VGND VGND VPWR VPWR sky130_fd_sc_hd__decap_3
X_4771_ _5040_/S _7005_/D _4760_/Y _4770_/X VGND VGND VPWR VPWR _4771_/X sky130_fd_sc_hd__o211a_2
X_6510_ _6638_/A VGND VGND VPWR VPWR _6510_/Y sky130_fd_sc_hd__inv_2
XFILLER_20_138 VGND VGND VPWR VPWR sky130_fd_sc_hd__fill_2
XFILLER_119_505 VGND VGND VPWR VPWR sky130_fd_sc_hd__decap_3
XTAP_TAPCELL_ROW_31_667 VGND VPWR sky130_fd_sc_hd__tapvpwrvgnd_1
XTAP_TAPCELL_ROW_99_1555 VGND VPWR sky130_fd_sc_hd__tapvpwrvgnd_1
XFILLER_119_538 VGND VGND VPWR VPWR sky130_fd_sc_hd__decap_3
X_6441_ _6638_/A VGND VGND VPWR VPWR _6441_/Y sky130_fd_sc_hd__inv_2
XFILLER_115_700 VGND VGND VPWR VPWR sky130_fd_sc_hd__decap_3
X_6372_ _6566_/A VGND VGND VPWR VPWR _6372_/Y sky130_fd_sc_hd__inv_2
X_3584_ _3424_/S _3583_/X _5648_/B VGND VGND VPWR VPWR _3586_/D sky130_fd_sc_hd__a21oi_2
X_5323_ _5323_/A0 _4945_/X _5344_/S VGND VGND VPWR VPWR _7169_/D sky130_fd_sc_hd__mux2_2
XFILLER_114_221 VGND VGND VPWR VPWR sky130_fd_sc_hd__decap_3
XFILLER_114_243 VGND VGND VPWR VPWR sky130_fd_sc_hd__fill_1
XTAP_TAPCELL_ROW_110_1700 VGND VPWR sky130_fd_sc_hd__tapvpwrvgnd_1
XFILLER_88_628 VGND VGND VPWR VPWR sky130_fd_sc_hd__decap_3
XFILLER_102_416 VGND VGND VPWR VPWR sky130_fd_sc_hd__fill_1
XFILLER_87_116 VGND VGND VPWR VPWR sky130_fd_sc_hd__decap_3
XFILLER_114_287 VGND VGND VPWR VPWR sky130_fd_sc_hd__fill_2
X_4205_ _4205_/A _4205_/B _4205_/C VGND VGND VPWR VPWR _4205_/X sky130_fd_sc_hd__and3_2
XFILLER_102_449 VGND VGND VPWR VPWR sky130_fd_sc_hd__decap_3
XFILLER_87_149 VGND VGND VPWR VPWR sky130_fd_sc_hd__decap_3
XTAP_TAPCELL_ROW_3_304 VGND VPWR sky130_fd_sc_hd__tapvpwrvgnd_1
XFILLER_29_706 VGND VGND VPWR VPWR sky130_fd_sc_hd__decap_3
XFILLER_96_672 VGND VGND VPWR VPWR sky130_fd_sc_hd__decap_3
X_4136_ _7235_/Q _4414_/A2 _4979_/S _7299_/Q _4135_/X VGND VGND VPWR VPWR _4136_/X
+ sky130_fd_sc_hd__a221o_2
XFILLER_110_471 VGND VGND VPWR VPWR sky130_fd_sc_hd__decap_3
XFILLER_28_227 VGND VGND VPWR VPWR sky130_fd_sc_hd__decap_3
XFILLER_113_15 VGND VGND VPWR VPWR sky130_fd_sc_hd__decap_3
XFILLER_113_48 VGND VGND VPWR VPWR sky130_fd_sc_hd__decap_3
X_4067_ _4068_/A _4082_/A VGND VGND VPWR VPWR _4744_/B sky130_fd_sc_hd__and2_2
XTAP_TAPCELL_ROW_39_778 VGND VPWR sky130_fd_sc_hd__tapvpwrvgnd_1
XFILLER_71_528 VGND VGND VPWR VPWR sky130_fd_sc_hd__decap_3
XFILLER_43_219 VGND VGND VPWR VPWR sky130_fd_sc_hd__decap_3
XTAP_TAPCELL_ROW_108_1673 VGND VPWR sky130_fd_sc_hd__tapvpwrvgnd_1
XFILLER_83_399 VGND VGND VPWR VPWR sky130_fd_sc_hd__decap_3
XFILLER_71_539 VGND VGND VPWR VPWR sky130_fd_sc_hd__decap_3
XFILLER_52_731 VGND VGND VPWR VPWR sky130_fd_sc_hd__decap_3
XFILLER_24_433 VGND VGND VPWR VPWR sky130_fd_sc_hd__fill_1
XTAP_TAPCELL_ROW_121_1840 VGND VPWR sky130_fd_sc_hd__tapvpwrvgnd_1
XFILLER_12_628 VGND VGND VPWR VPWR sky130_fd_sc_hd__decap_3
XTAP_TAPCELL_ROW_50_921 VGND VPWR sky130_fd_sc_hd__tapvpwrvgnd_1
X_4969_ _4968_/Y _4969_/B _4969_/C VGND VGND VPWR VPWR _4969_/X sky130_fd_sc_hd__and3b_2
XFILLER_11_116 VGND VGND VPWR VPWR sky130_fd_sc_hd__decap_3
X_6708_ _6942_/CLK _6708_/D VGND VGND VPWR VPWR _6708_/Q sky130_fd_sc_hd__dfxtp_2
XFILLER_22_23 VGND VGND VPWR VPWR sky130_fd_sc_hd__decap_3
XFILLER_20_672 VGND VGND VPWR VPWR sky130_fd_sc_hd__decap_3
X_6639_ _6640_/A VGND VGND VPWR VPWR _6639_/Y sky130_fd_sc_hd__inv_2
XTAP_TAPCELL_ROW_59_1038 VGND VPWR sky130_fd_sc_hd__tapvpwrvgnd_1
XFILLER_118_560 VGND VGND VPWR VPWR sky130_fd_sc_hd__decap_3
XFILLER_98_27 VGND VGND VPWR VPWR sky130_fd_sc_hd__fill_1
XFILLER_106_722 VGND VGND VPWR VPWR sky130_fd_sc_hd__decap_3
XFILLER_3_337 VGND VGND VPWR VPWR sky130_fd_sc_hd__fill_2
XTAP_TAPCELL_ROW_72_1205 VGND VPWR sky130_fd_sc_hd__tapvpwrvgnd_1
XFILLER_79_606 VGND VGND VPWR VPWR sky130_fd_sc_hd__decap_3
XFILLER_121_703 VGND VGND VPWR VPWR sky130_fd_sc_hd__decap_3
XFILLER_79_617 VGND VGND VPWR VPWR sky130_fd_sc_hd__decap_3
Xoutput480 _5652_/Y VGND VGND VPWR VPWR alu_result_out[27] sky130_fd_sc_hd__clkdlybuf4s25_1
XPHY_EDGE_ROW_110_Right_110 VGND VGND VPWR VPWR sky130_fd_sc_hd__decap_3
Xoutput491 _5651_/Y VGND VGND VPWR VPWR alu_result_out[8] sky130_fd_sc_hd__clkdlybuf4s25_1
XFILLER_78_127 VGND VGND VPWR VPWR sky130_fd_sc_hd__decap_3
XFILLER_120_246 VGND VGND VPWR VPWR sky130_fd_sc_hd__decap_3
XFILLER_87_650 VGND VGND VPWR VPWR sky130_fd_sc_hd__decap_3
XFILLER_120_268 VGND VGND VPWR VPWR sky130_fd_sc_hd__decap_3
XFILLER_93_119 VGND VGND VPWR VPWR sky130_fd_sc_hd__decap_3
XFILLER_86_160 VGND VGND VPWR VPWR sky130_fd_sc_hd__decap_3
XFILLER_59_374 VGND VGND VPWR VPWR sky130_fd_sc_hd__decap_3
XFILLER_87_694 VGND VGND VPWR VPWR sky130_fd_sc_hd__decap_3
XFILLER_74_322 VGND VGND VPWR VPWR sky130_fd_sc_hd__fill_2
XFILLER_59_396 VGND VGND VPWR VPWR sky130_fd_sc_hd__decap_3
XFILLER_101_482 VGND VGND VPWR VPWR sky130_fd_sc_hd__decap_3
XFILLER_86_193 VGND VGND VPWR VPWR sky130_fd_sc_hd__decap_3
XFILLER_35_709 VGND VGND VPWR VPWR sky130_fd_sc_hd__decap_3
XFILLER_74_377 VGND VGND VPWR VPWR sky130_fd_sc_hd__decap_3
XFILLER_62_517 VGND VGND VPWR VPWR sky130_fd_sc_hd__decap_3
XFILLER_34_219 VGND VGND VPWR VPWR sky130_fd_sc_hd__decap_3
XFILLER_27_260 VGND VGND VPWR VPWR sky130_fd_sc_hd__fill_2
XFILLER_15_411 VGND VGND VPWR VPWR sky130_fd_sc_hd__fill_1
XFILLER_15_422 VGND VGND VPWR VPWR sky130_fd_sc_hd__decap_3
XFILLER_103_81 VGND VGND VPWR VPWR sky130_fd_sc_hd__decap_3
XFILLER_103_92 VGND VGND VPWR VPWR sky130_fd_sc_hd__decap_3
XTAP_TAPCELL_ROW_83_1345 VGND VPWR sky130_fd_sc_hd__tapvpwrvgnd_1
XFILLER_42_230 VGND VGND VPWR VPWR sky130_fd_sc_hd__decap_3
XFILLER_70_572 VGND VGND VPWR VPWR sky130_fd_sc_hd__fill_2
XFILLER_30_403 VGND VGND VPWR VPWR sky130_fd_sc_hd__decap_3
XFILLER_42_285 VGND VGND VPWR VPWR sky130_fd_sc_hd__decap_3
XFILLER_15_499 VGND VGND VPWR VPWR sky130_fd_sc_hd__decap_3
XFILLER_11_650 VGND VGND VPWR VPWR sky130_fd_sc_hd__decap_3
XFILLER_7_632 VGND VGND VPWR VPWR sky130_fd_sc_hd__decap_3
XFILLER_11_694 VGND VGND VPWR VPWR sky130_fd_sc_hd__decap_3
XFILLER_10_171 VGND VGND VPWR VPWR sky130_fd_sc_hd__fill_2
XFILLER_7_665 VGND VGND VPWR VPWR sky130_fd_sc_hd__decap_3
XFILLER_7_676 VGND VGND VPWR VPWR sky130_fd_sc_hd__decap_3
XFILLER_109_582 VGND VGND VPWR VPWR sky130_fd_sc_hd__decap_3
XFILLER_6_197 VGND VGND VPWR VPWR sky130_fd_sc_hd__fill_2
XTAP_TAPCELL_ROW_94_1485 VGND VPWR sky130_fd_sc_hd__tapvpwrvgnd_1
XFILLER_88_60 VGND VGND VPWR VPWR sky130_fd_sc_hd__decap_3
XFILLER_112_725 VGND VGND VPWR VPWR sky130_fd_sc_hd__decap_3
XFILLER_97_425 VGND VGND VPWR VPWR sky130_fd_sc_hd__decap_3
XFILLER_69_116 VGND VGND VPWR VPWR sky130_fd_sc_hd__decap_3
XFILLER_97_458 VGND VGND VPWR VPWR sky130_fd_sc_hd__fill_1
XFILLER_69_149 VGND VGND VPWR VPWR sky130_fd_sc_hd__decap_3
XFILLER_111_235 VGND VGND VPWR VPWR sky130_fd_sc_hd__decap_3
XFILLER_85_609 VGND VGND VPWR VPWR sky130_fd_sc_hd__decap_3
XFILLER_111_268 VGND VGND VPWR VPWR sky130_fd_sc_hd__decap_3
XFILLER_78_672 VGND VGND VPWR VPWR sky130_fd_sc_hd__decap_3
XFILLER_93_620 VGND VGND VPWR VPWR sky130_fd_sc_hd__decap_3
XFILLER_65_311 VGND VGND VPWR VPWR sky130_fd_sc_hd__decap_3
XFILLER_38_525 VGND VGND VPWR VPWR sky130_fd_sc_hd__decap_3
XFILLER_77_193 VGND VGND VPWR VPWR sky130_fd_sc_hd__decap_3
XFILLER_93_653 VGND VGND VPWR VPWR sky130_fd_sc_hd__decap_3
XFILLER_92_130 VGND VGND VPWR VPWR sky130_fd_sc_hd__fill_1
X_6990_ _7401_/CLK _6990_/D _6270_/Y VGND VGND VPWR VPWR _6990_/Q sky130_fd_sc_hd__dfrtp_2
XFILLER_53_517 VGND VGND VPWR VPWR sky130_fd_sc_hd__decap_3
XFILLER_25_208 VGND VGND VPWR VPWR sky130_fd_sc_hd__fill_1
XFILLER_65_377 VGND VGND VPWR VPWR sky130_fd_sc_hd__decap_3
XFILLER_93_697 VGND VGND VPWR VPWR sky130_fd_sc_hd__decap_3
XFILLER_92_174 VGND VGND VPWR VPWR sky130_fd_sc_hd__decap_3
XTAP_TAPCELL_ROW_36_737 VGND VPWR sky130_fd_sc_hd__tapvpwrvgnd_1
XFILLER_80_336 VGND VGND VPWR VPWR sky130_fd_sc_hd__decap_3
XFILLER_34_731 VGND VGND VPWR VPWR sky130_fd_sc_hd__decap_3
X_4823_ _4823_/A0 _4822_/X _4914_/S VGND VGND VPWR VPWR _7272_/D sky130_fd_sc_hd__mux2_2
XTAP_TAPCELL_ROW_16_472 VGND VPWR sky130_fd_sc_hd__tapvpwrvgnd_1
XFILLER_21_447 VGND VGND VPWR VPWR sky130_fd_sc_hd__fill_1
X_3705_ _3705_/A0 _3704_/X _4832_/A VGND VGND VPWR VPWR _7400_/D sky130_fd_sc_hd__mux2_2
XFILLER_119_335 VGND VGND VPWR VPWR sky130_fd_sc_hd__fill_1
XFILLER_119_346 VGND VGND VPWR VPWR sky130_fd_sc_hd__decap_3
X_4685_ _6996_/Q _4668_/X _4928_/B _4684_/X VGND VGND VPWR VPWR _4858_/B sky130_fd_sc_hd__a31o_2
XFILLER_107_508 VGND VGND VPWR VPWR sky130_fd_sc_hd__decap_3
X_3636_ _3636_/A _3636_/B VGND VGND VPWR VPWR _3636_/Y sky130_fd_sc_hd__nor2_2
X_6424_ _6654_/A VGND VGND VPWR VPWR _6424_/Y sky130_fd_sc_hd__inv_2
XFILLER_108_26 VGND VGND VPWR VPWR sky130_fd_sc_hd__fill_2
X_6355_ _6363_/A VGND VGND VPWR VPWR _6355_/Y sky130_fd_sc_hd__inv_2
X_3567_ _7221_/Q _4307_/A2 _4528_/B _7034_/Q _3566_/X VGND VGND VPWR VPWR _3567_/X
+ sky130_fd_sc_hd__a221o_2
XFILLER_115_541 VGND VGND VPWR VPWR sky130_fd_sc_hd__decap_3
XFILLER_103_703 VGND VGND VPWR VPWR sky130_fd_sc_hd__decap_3
X_5306_ _5306_/A0 _4806_/X _5315_/S VGND VGND VPWR VPWR _7177_/D sky130_fd_sc_hd__mux2_2
X_6286_ _6288_/A VGND VGND VPWR VPWR _6286_/Y sky130_fd_sc_hd__inv_2
XFILLER_115_585 VGND VGND VPWR VPWR sky130_fd_sc_hd__decap_3
X_3498_ _3857_/A2 _3442_/B _3449_/B VGND VGND VPWR VPWR _5152_/B sky130_fd_sc_hd__a21oi_2
XFILLER_88_458 VGND VGND VPWR VPWR sky130_fd_sc_hd__fill_1
XFILLER_69_650 VGND VGND VPWR VPWR sky130_fd_sc_hd__decap_3
XFILLER_75_108 VGND VGND VPWR VPWR sky130_fd_sc_hd__decap_3
XFILLER_69_694 VGND VGND VPWR VPWR sky130_fd_sc_hd__decap_3
XFILLER_96_480 VGND VGND VPWR VPWR sky130_fd_sc_hd__decap_3
XFILLER_84_631 VGND VGND VPWR VPWR sky130_fd_sc_hd__decap_3
XFILLER_84_29 VGND VGND VPWR VPWR sky130_fd_sc_hd__fill_1
X_4119_ _7236_/Q _4414_/A2 _4268_/B1 _7396_/Q _4118_/X VGND VGND VPWR VPWR _4119_/X
+ sky130_fd_sc_hd__a221o_2
XFILLER_29_558 VGND VGND VPWR VPWR sky130_fd_sc_hd__fill_2
XFILLER_56_355 VGND VGND VPWR VPWR sky130_fd_sc_hd__decap_3
XFILLER_17_709 VGND VGND VPWR VPWR sky130_fd_sc_hd__decap_3
X_5099_ _5099_/A _5100_/A VGND VGND VPWR VPWR _5099_/X sky130_fd_sc_hd__or2_2
XFILLER_83_141 VGND VGND VPWR VPWR sky130_fd_sc_hd__decap_3
XFILLER_84_675 VGND VGND VPWR VPWR sky130_fd_sc_hd__decap_3
XFILLER_56_377 VGND VGND VPWR VPWR sky130_fd_sc_hd__decap_3
XFILLER_16_219 VGND VGND VPWR VPWR sky130_fd_sc_hd__decap_3
XFILLER_56_399 VGND VGND VPWR VPWR sky130_fd_sc_hd__decap_3
XFILLER_37_591 VGND VGND VPWR VPWR sky130_fd_sc_hd__decap_3
XFILLER_71_369 VGND VGND VPWR VPWR sky130_fd_sc_hd__decap_3
XFILLER_40_701 VGND VGND VPWR VPWR sky130_fd_sc_hd__decap_3
XFILLER_12_414 VGND VGND VPWR VPWR sky130_fd_sc_hd__decap_3
XFILLER_24_274 VGND VGND VPWR VPWR sky130_fd_sc_hd__decap_3
XFILLER_40_734 VGND VGND VPWR VPWR sky130_fd_sc_hd__fill_1
XFILLER_8_407 VGND VGND VPWR VPWR sky130_fd_sc_hd__decap_3
XFILLER_12_458 VGND VGND VPWR VPWR sky130_fd_sc_hd__decap_3
XFILLER_4_613 VGND VGND VPWR VPWR sky130_fd_sc_hd__decap_3
XFILLER_4_657 VGND VGND VPWR VPWR sky130_fd_sc_hd__decap_3
XPHY_EDGE_ROW_18_Left_142 VGND VGND VPWR VPWR sky130_fd_sc_hd__decap_3
XFILLER_106_563 VGND VGND VPWR VPWR sky130_fd_sc_hd__decap_3
XFILLER_79_414 VGND VGND VPWR VPWR sky130_fd_sc_hd__decap_3
XFILLER_121_500 VGND VGND VPWR VPWR sky130_fd_sc_hd__decap_3
XFILLER_121_511 VGND VGND VPWR VPWR sky130_fd_sc_hd__decap_3
XFILLER_79_436 VGND VGND VPWR VPWR sky130_fd_sc_hd__decap_3
XFILLER_121_544 VGND VGND VPWR VPWR sky130_fd_sc_hd__decap_3
XFILLER_67_609 VGND VGND VPWR VPWR sky130_fd_sc_hd__decap_3
XFILLER_94_417 VGND VGND VPWR VPWR sky130_fd_sc_hd__decap_3
XFILLER_58_85 VGND VGND VPWR VPWR sky130_fd_sc_hd__fill_2
XFILLER_121_588 VGND VGND VPWR VPWR sky130_fd_sc_hd__decap_3
XFILLER_94_439 VGND VGND VPWR VPWR sky130_fd_sc_hd__decap_3
XFILLER_75_620 VGND VGND VPWR VPWR sky130_fd_sc_hd__decap_3
XFILLER_47_322 VGND VGND VPWR VPWR sky130_fd_sc_hd__decap_3
XFILLER_59_193 VGND VGND VPWR VPWR sky130_fd_sc_hd__decap_3
XFILLER_75_653 VGND VGND VPWR VPWR sky130_fd_sc_hd__decap_3
XFILLER_74_130 VGND VGND VPWR VPWR sky130_fd_sc_hd__fill_1
XFILLER_74_141 VGND VGND VPWR VPWR sky130_fd_sc_hd__decap_3
XFILLER_90_601 VGND VGND VPWR VPWR sky130_fd_sc_hd__decap_3
XFILLER_114_80 VGND VGND VPWR VPWR sky130_fd_sc_hd__decap_3
XFILLER_35_517 VGND VGND VPWR VPWR sky130_fd_sc_hd__decap_3
XFILLER_75_697 VGND VGND VPWR VPWR sky130_fd_sc_hd__decap_3
XFILLER_74_174 VGND VGND VPWR VPWR sky130_fd_sc_hd__decap_3
XPHY_EDGE_ROW_27_Left_151 VGND VGND VPWR VPWR sky130_fd_sc_hd__decap_3
XFILLER_90_634 VGND VGND VPWR VPWR sky130_fd_sc_hd__decap_3
XFILLER_28_580 VGND VGND VPWR VPWR sky130_fd_sc_hd__decap_3
XFILLER_90_645 VGND VGND VPWR VPWR sky130_fd_sc_hd__decap_3
XFILLER_16_731 VGND VGND VPWR VPWR sky130_fd_sc_hd__decap_3
XFILLER_90_678 VGND VGND VPWR VPWR sky130_fd_sc_hd__decap_3
XFILLER_43_561 VGND VGND VPWR VPWR sky130_fd_sc_hd__decap_3
XFILLER_31_712 VGND VGND VPWR VPWR sky130_fd_sc_hd__decap_3
XFILLER_15_274 VGND VGND VPWR VPWR sky130_fd_sc_hd__fill_2
XFILLER_30_222 VGND VGND VPWR VPWR sky130_fd_sc_hd__fill_2
XFILLER_70_391 VGND VGND VPWR VPWR sky130_fd_sc_hd__decap_3
XTAP_TAPCELL_ROW_13_431 VGND VPWR sky130_fd_sc_hd__tapvpwrvgnd_1
XTAP_TAPCELL_ROW_13_442 VGND VPWR sky130_fd_sc_hd__tapvpwrvgnd_1
XFILLER_90_83 VGND VGND VPWR VPWR sky130_fd_sc_hd__fill_1
XFILLER_30_277 VGND VGND VPWR VPWR sky130_fd_sc_hd__fill_1
XFILLER_30_288 VGND VGND VPWR VPWR sky130_fd_sc_hd__decap_3
XTAP_TAPCELL_ROW_41_795 VGND VPWR sky130_fd_sc_hd__tapvpwrvgnd_1
XTAP_TAPCELL_ROW_96_1514 VGND VPWR sky130_fd_sc_hd__tapvpwrvgnd_1
XFILLER_7_462 VGND VGND VPWR VPWR sky130_fd_sc_hd__decap_3
X_4470_ _3346_/A _3927_/X _4466_/Y _4469_/X VGND VGND VPWR VPWR _4470_/X sky130_fd_sc_hd__a31o_2
XPHY_EDGE_ROW_36_Left_160 VGND VGND VPWR VPWR sky130_fd_sc_hd__decap_3
X_3421_ _4537_/B _3421_/B _3421_/C VGND VGND VPWR VPWR _5688_/S sky130_fd_sc_hd__or3_4
XFILLER_98_701 VGND VGND VPWR VPWR sky130_fd_sc_hd__decap_3
X_3352_ _3420_/A _5642_/B VGND VGND VPWR VPWR _3469_/B sky130_fd_sc_hd__nor2_2
XFILLER_97_200 VGND VGND VPWR VPWR sky130_fd_sc_hd__decap_3
XFILLER_98_734 VGND VGND VPWR VPWR sky130_fd_sc_hd__fill_1
XFILLER_97_222 VGND VGND VPWR VPWR sky130_fd_sc_hd__fill_2
XFILLER_112_522 VGND VGND VPWR VPWR sky130_fd_sc_hd__decap_3
XFILLER_112_533 VGND VGND VPWR VPWR sky130_fd_sc_hd__decap_3
XFILLER_112_566 VGND VGND VPWR VPWR sky130_fd_sc_hd__decap_3
X_5022_ _4948_/A _5017_/Y _5020_/X _5021_/X VGND VGND VPWR VPWR _5661_/A sky130_fd_sc_hd__o211a_2
Xhold1107 _7224_/Q VGND VGND VPWR VPWR _5209_/A sky130_fd_sc_hd__dlygate4sd3_1
XFILLER_100_728 VGND VGND VPWR VPWR sky130_fd_sc_hd__decap_3
Xhold1118 _7172_/Q VGND VGND VPWR VPWR _5317_/A0 sky130_fd_sc_hd__dlygate4sd3_1
Xhold1129 _7177_/Q VGND VGND VPWR VPWR _5306_/A0 sky130_fd_sc_hd__dlygate4sd3_1
XFILLER_97_299 VGND VGND VPWR VPWR sky130_fd_sc_hd__decap_3
XFILLER_78_480 VGND VGND VPWR VPWR sky130_fd_sc_hd__decap_3
XFILLER_66_642 VGND VGND VPWR VPWR sky130_fd_sc_hd__fill_2
XFILLER_66_675 VGND VGND VPWR VPWR sky130_fd_sc_hd__decap_3
XFILLER_26_506 VGND VGND VPWR VPWR sky130_fd_sc_hd__fill_2
XFILLER_81_612 VGND VGND VPWR VPWR sky130_fd_sc_hd__decap_3
XFILLER_81_623 VGND VGND VPWR VPWR sky130_fd_sc_hd__decap_3
XFILLER_80_100 VGND VGND VPWR VPWR sky130_fd_sc_hd__decap_3
XFILLER_53_314 VGND VGND VPWR VPWR sky130_fd_sc_hd__decap_3
XFILLER_38_399 VGND VGND VPWR VPWR sky130_fd_sc_hd__decap_3
X_6973_ _6978_/CLK _6973_/D VGND VGND VPWR VPWR _6973_/Q sky130_fd_sc_hd__dfxtp_2
XFILLER_81_656 VGND VGND VPWR VPWR sky130_fd_sc_hd__decap_3
XFILLER_80_122 VGND VGND VPWR VPWR sky130_fd_sc_hd__fill_2
XFILLER_19_591 VGND VGND VPWR VPWR sky130_fd_sc_hd__decap_3
XTAP_TAPCELL_ROW_105_1632 VGND VPWR sky130_fd_sc_hd__tapvpwrvgnd_1
XFILLER_80_144 VGND VGND VPWR VPWR sky130_fd_sc_hd__decap_3
XFILLER_34_561 VGND VGND VPWR VPWR sky130_fd_sc_hd__decap_3
XFILLER_22_701 VGND VGND VPWR VPWR sky130_fd_sc_hd__decap_3
XFILLER_80_177 VGND VGND VPWR VPWR sky130_fd_sc_hd__decap_3
XFILLER_110_27 VGND VGND VPWR VPWR sky130_fd_sc_hd__fill_1
XFILLER_110_38 VGND VGND VPWR VPWR sky130_fd_sc_hd__decap_3
XFILLER_22_734 VGND VGND VPWR VPWR sky130_fd_sc_hd__fill_1
XFILLER_21_211 VGND VGND VPWR VPWR sky130_fd_sc_hd__decap_3
XFILLER_21_222 VGND VGND VPWR VPWR sky130_fd_sc_hd__fill_2
X_4806_ _3346_/A _3701_/X _4799_/X _4805_/X VGND VGND VPWR VPWR _4806_/X sky130_fd_sc_hd__a31o_2
XFILLER_21_255 VGND VGND VPWR VPWR sky130_fd_sc_hd__decap_3
XFILLER_21_299 VGND VGND VPWR VPWR sky130_fd_sc_hd__decap_3
X_4737_ _7005_/Q _4775_/A _7006_/Q VGND VGND VPWR VPWR _4738_/B sky130_fd_sc_hd__a21oi_2
XFILLER_119_143 VGND VGND VPWR VPWR sky130_fd_sc_hd__fill_2
XFILLER_119_36 VGND VGND VPWR VPWR sky130_fd_sc_hd__decap_3
XFILLER_119_154 VGND VGND VPWR VPWR sky130_fd_sc_hd__fill_2
XFILLER_119_176 VGND VGND VPWR VPWR sky130_fd_sc_hd__decap_3
X_4668_ _4908_/A _4896_/A VGND VGND VPWR VPWR _4668_/X sky130_fd_sc_hd__and2_2
XFILLER_107_327 VGND VGND VPWR VPWR sky130_fd_sc_hd__decap_3
XFILLER_119_69 VGND VGND VPWR VPWR sky130_fd_sc_hd__decap_3
X_3619_ _3620_/A _3620_/C _4292_/B VGND VGND VPWR VPWR _3619_/Y sky130_fd_sc_hd__o21ai_2
X_6407_ _6633_/A VGND VGND VPWR VPWR _6407_/Y sky130_fd_sc_hd__inv_2
Xhold930 _6700_/Q VGND VGND VPWR VPWR hold930/X sky130_fd_sc_hd__dlygate4sd3_1
XTAP_TAPCELL_ROW_116_1772 VGND VPWR sky130_fd_sc_hd__tapvpwrvgnd_1
X_4599_ _7281_/Q _5142_/A0 _4601_/S VGND VGND VPWR VPWR _4599_/X sky130_fd_sc_hd__mux2_2
Xhold941 _7050_/Q VGND VGND VPWR VPWR hold941/X sky130_fd_sc_hd__dlygate4sd3_1
X_7387_ _7387_/CLK _7387_/D _6667_/Y VGND VGND VPWR VPWR _7387_/Q sky130_fd_sc_hd__dfrtp_2
Xhold952 _7382_/Q VGND VGND VPWR VPWR hold952/X sky130_fd_sc_hd__dlygate4sd3_1
Xhold963 _7014_/Q VGND VGND VPWR VPWR _5628_/A sky130_fd_sc_hd__dlygate4sd3_1
XFILLER_89_712 VGND VGND VPWR VPWR sky130_fd_sc_hd__decap_3
XFILLER_88_200 VGND VGND VPWR VPWR sky130_fd_sc_hd__decap_3
X_6338_ _6591_/A VGND VGND VPWR VPWR _6338_/Y sky130_fd_sc_hd__inv_2
Xhold974 _7049_/Q VGND VGND VPWR VPWR hold974/X sky130_fd_sc_hd__dlygate4sd3_1
Xhold985 _7239_/Q VGND VGND VPWR VPWR _5177_/A sky130_fd_sc_hd__dlygate4sd3_1
XFILLER_1_638 VGND VGND VPWR VPWR sky130_fd_sc_hd__decap_3
XFILLER_115_382 VGND VGND VPWR VPWR sky130_fd_sc_hd__decap_3
Xhold996 _7313_/Q VGND VGND VPWR VPWR hold996/X sky130_fd_sc_hd__dlygate4sd3_1
XFILLER_115_393 VGND VGND VPWR VPWR sky130_fd_sc_hd__decap_3
XFILLER_103_544 VGND VGND VPWR VPWR sky130_fd_sc_hd__decap_3
XFILLER_88_244 VGND VGND VPWR VPWR sky130_fd_sc_hd__decap_3
X_6269_ _6363_/A VGND VGND VPWR VPWR _6269_/Y sky130_fd_sc_hd__inv_2
XFILLER_49_609 VGND VGND VPWR VPWR sky130_fd_sc_hd__decap_3
XFILLER_88_277 VGND VGND VPWR VPWR sky130_fd_sc_hd__decap_3
XFILLER_103_588 VGND VGND VPWR VPWR sky130_fd_sc_hd__decap_3
XFILLER_57_620 VGND VGND VPWR VPWR sky130_fd_sc_hd__decap_3
XFILLER_57_653 VGND VGND VPWR VPWR sky130_fd_sc_hd__decap_3
XFILLER_56_130 VGND VGND VPWR VPWR sky130_fd_sc_hd__decap_3
XFILLER_56_141 VGND VGND VPWR VPWR sky130_fd_sc_hd__decap_3
XFILLER_84_461 VGND VGND VPWR VPWR sky130_fd_sc_hd__decap_3
XFILLER_72_601 VGND VGND VPWR VPWR sky130_fd_sc_hd__decap_3
XFILLER_84_472 VGND VGND VPWR VPWR sky130_fd_sc_hd__decap_3
XFILLER_29_377 VGND VGND VPWR VPWR sky130_fd_sc_hd__decap_3
XFILLER_57_697 VGND VGND VPWR VPWR sky130_fd_sc_hd__decap_3
XFILLER_28_99 VGND VGND VPWR VPWR sky130_fd_sc_hd__fill_2
XFILLER_72_634 VGND VGND VPWR VPWR sky130_fd_sc_hd__decap_3
XTAP_TAPCELL_ROW_67_1137 VGND VPWR sky130_fd_sc_hd__tapvpwrvgnd_1
XFILLER_72_645 VGND VGND VPWR VPWR sky130_fd_sc_hd__decap_3
XFILLER_71_133 VGND VGND VPWR VPWR sky130_fd_sc_hd__fill_1
XFILLER_72_678 VGND VGND VPWR VPWR sky130_fd_sc_hd__decap_3
XFILLER_44_32 VGND VGND VPWR VPWR sky130_fd_sc_hd__fill_1
XFILLER_71_166 VGND VGND VPWR VPWR sky130_fd_sc_hd__fill_2
XFILLER_25_561 VGND VGND VPWR VPWR sky130_fd_sc_hd__decap_3
XTAP_TAPCELL_ROW_80_1304 VGND VPWR sky130_fd_sc_hd__tapvpwrvgnd_1
XFILLER_44_54 VGND VGND VPWR VPWR sky130_fd_sc_hd__decap_3
XFILLER_13_712 VGND VGND VPWR VPWR sky130_fd_sc_hd__decap_3
XFILLER_25_594 VGND VGND VPWR VPWR sky130_fd_sc_hd__decap_3
XFILLER_40_531 VGND VGND VPWR VPWR sky130_fd_sc_hd__fill_1
XFILLER_40_542 VGND VGND VPWR VPWR sky130_fd_sc_hd__decap_3
XFILLER_9_727 VGND VGND VPWR VPWR sky130_fd_sc_hd__fill_1
XTAP_TAPCELL_ROW_10_401 VGND VPWR sky130_fd_sc_hd__tapvpwrvgnd_1
XFILLER_12_288 VGND VGND VPWR VPWR sky130_fd_sc_hd__decap_3
XFILLER_100_82 VGND VGND VPWR VPWR sky130_fd_sc_hd__fill_2
XFILLER_8_259 VGND VGND VPWR VPWR sky130_fd_sc_hd__decap_3
XFILLER_4_421 VGND VGND VPWR VPWR sky130_fd_sc_hd__decap_3
XTAP_TAPCELL_ROW_78_1277 VGND VPWR sky130_fd_sc_hd__tapvpwrvgnd_1
XFILLER_4_443 VGND VGND VPWR VPWR sky130_fd_sc_hd__decap_3
XFILLER_69_51 VGND VGND VPWR VPWR sky130_fd_sc_hd__decap_3
XTAP_TAPCELL_ROW_91_1444 VGND VPWR sky130_fd_sc_hd__tapvpwrvgnd_1
XTAP_TAPCELL_ROW_91_1455 VGND VPWR sky130_fd_sc_hd__tapvpwrvgnd_1
XFILLER_79_222 VGND VGND VPWR VPWR sky130_fd_sc_hd__fill_2
XFILLER_106_393 VGND VGND VPWR VPWR sky130_fd_sc_hd__decap_3
XFILLER_79_244 VGND VGND VPWR VPWR sky130_fd_sc_hd__decap_3
XFILLER_95_715 VGND VGND VPWR VPWR sky130_fd_sc_hd__decap_3
XFILLER_94_203 VGND VGND VPWR VPWR sky130_fd_sc_hd__decap_3
XFILLER_39_108 VGND VGND VPWR VPWR sky130_fd_sc_hd__decap_3
XFILLER_0_671 VGND VGND VPWR VPWR sky130_fd_sc_hd__fill_1
XFILLER_94_236 VGND VGND VPWR VPWR sky130_fd_sc_hd__decap_3
XFILLER_48_642 VGND VGND VPWR VPWR sky130_fd_sc_hd__fill_2
XPHY_EDGE_ROW_13_Right_13 VGND VGND VPWR VPWR sky130_fd_sc_hd__decap_3
XFILLER_82_409 VGND VGND VPWR VPWR sky130_fd_sc_hd__fill_1
XFILLER_48_675 VGND VGND VPWR VPWR sky130_fd_sc_hd__decap_3
XFILLER_85_94 VGND VGND VPWR VPWR sky130_fd_sc_hd__decap_3
XFILLER_47_163 VGND VGND VPWR VPWR sky130_fd_sc_hd__decap_3
XTAP_TAPCELL_ROW_18_501 VGND VPWR sky130_fd_sc_hd__tapvpwrvgnd_1
XFILLER_63_623 VGND VGND VPWR VPWR sky130_fd_sc_hd__decap_3
XFILLER_35_314 VGND VGND VPWR VPWR sky130_fd_sc_hd__decap_3
XFILLER_47_185 VGND VGND VPWR VPWR sky130_fd_sc_hd__decap_3
XFILLER_63_656 VGND VGND VPWR VPWR sky130_fd_sc_hd__decap_3
XFILLER_35_347 VGND VGND VPWR VPWR sky130_fd_sc_hd__decap_3
XFILLER_35_358 VGND VGND VPWR VPWR sky130_fd_sc_hd__fill_1
XTAP_TAPCELL_ROW_46_865 VGND VPWR sky130_fd_sc_hd__tapvpwrvgnd_1
XFILLER_62_144 VGND VGND VPWR VPWR sky130_fd_sc_hd__fill_2
X_3970_ _7355_/Q _4513_/A0 _3989_/S VGND VGND VPWR VPWR _7355_/D sky130_fd_sc_hd__mux2_2
XFILLER_62_166 VGND VGND VPWR VPWR sky130_fd_sc_hd__decap_3
XFILLER_16_561 VGND VGND VPWR VPWR sky130_fd_sc_hd__decap_3
XFILLER_50_339 VGND VGND VPWR VPWR sky130_fd_sc_hd__decap_3
XFILLER_43_380 VGND VGND VPWR VPWR sky130_fd_sc_hd__fill_1
X_5640_ _5642_/A _5640_/B VGND VGND VPWR VPWR _5640_/Y sky130_fd_sc_hd__nor2_2
XFILLER_86_3 VGND VGND VPWR VPWR sky130_fd_sc_hd__decap_3
XTAP_TAPCELL_ROW_100_1562 VGND VPWR sky130_fd_sc_hd__tapvpwrvgnd_1
XTAP_TAPCELL_ROW_100_1573 VGND VPWR sky130_fd_sc_hd__tapvpwrvgnd_1
XFILLER_31_597 VGND VGND VPWR VPWR sky130_fd_sc_hd__decap_3
XPHY_EDGE_ROW_22_Right_22 VGND VGND VPWR VPWR sky130_fd_sc_hd__decap_3
X_5571_ hold934/X _4909_/A _4944_/C VGND VGND VPWR VPWR _7046_/D sky130_fd_sc_hd__a21o_2
XFILLER_117_603 VGND VGND VPWR VPWR sky130_fd_sc_hd__decap_3
X_4522_ _4522_/A0 _7286_/Q _4528_/B VGND VGND VPWR VPWR _7318_/D sky130_fd_sc_hd__mux2_2
X_7310_ _7374_/CLK _7310_/D _6590_/Y VGND VGND VPWR VPWR _7310_/Q sky130_fd_sc_hd__dfrtp_2
XFILLER_117_647 VGND VGND VPWR VPWR sky130_fd_sc_hd__decap_3
X_4453_ _4453_/A VGND VGND VPWR VPWR _4762_/B sky130_fd_sc_hd__inv_2
X_7241_ _7404_/CLK _7241_/D _6521_/Y VGND VGND VPWR VPWR _7241_/Q sky130_fd_sc_hd__dfrtp_2
X_7172_ _7360_/CLK _7172_/D _6452_/Y VGND VGND VPWR VPWR _7172_/Q sky130_fd_sc_hd__dfrtp_2
X_4384_ _4384_/A _4968_/A _4384_/C VGND VGND VPWR VPWR _4778_/B sky130_fd_sc_hd__nand3_2
X_3335_ _3319_/X _5238_/B _3329_/Y _3339_/C1 VGND VGND VPWR VPWR _3442_/A sky130_fd_sc_hd__a211o_2
XFILLER_98_553 VGND VGND VPWR VPWR sky130_fd_sc_hd__decap_3
XFILLER_86_704 VGND VGND VPWR VPWR sky130_fd_sc_hd__decap_3
XFILLER_112_341 VGND VGND VPWR VPWR sky130_fd_sc_hd__decap_3
XFILLER_98_586 VGND VGND VPWR VPWR sky130_fd_sc_hd__fill_2
XFILLER_105_27 VGND VGND VPWR VPWR sky130_fd_sc_hd__decap_3
XFILLER_58_439 VGND VGND VPWR VPWR sky130_fd_sc_hd__decap_3
XPHY_EDGE_ROW_31_Right_31 VGND VGND VPWR VPWR sky130_fd_sc_hd__decap_3
XFILLER_85_225 VGND VGND VPWR VPWR sky130_fd_sc_hd__decap_3
XFILLER_39_620 VGND VGND VPWR VPWR sky130_fd_sc_hd__decap_3
XFILLER_100_536 VGND VGND VPWR VPWR sky130_fd_sc_hd__fill_2
XFILLER_112_396 VGND VGND VPWR VPWR sky130_fd_sc_hd__decap_3
XFILLER_85_247 VGND VGND VPWR VPWR sky130_fd_sc_hd__decap_3
X_5005_ _5004_/A _5004_/B _4814_/A VGND VGND VPWR VPWR _5005_/Y sky130_fd_sc_hd__a21oi_2
XFILLER_39_653 VGND VGND VPWR VPWR sky130_fd_sc_hd__decap_3
XFILLER_73_409 VGND VGND VPWR VPWR sky130_fd_sc_hd__decap_3
XFILLER_66_450 VGND VGND VPWR VPWR sky130_fd_sc_hd__decap_3
XFILLER_54_601 VGND VGND VPWR VPWR sky130_fd_sc_hd__decap_3
XFILLER_38_163 VGND VGND VPWR VPWR sky130_fd_sc_hd__decap_3
XFILLER_66_483 VGND VGND VPWR VPWR sky130_fd_sc_hd__decap_3
XFILLER_53_100 VGND VGND VPWR VPWR sky130_fd_sc_hd__decap_3
XFILLER_39_697 VGND VGND VPWR VPWR sky130_fd_sc_hd__decap_3
XFILLER_54_634 VGND VGND VPWR VPWR sky130_fd_sc_hd__decap_3
XFILLER_53_111 VGND VGND VPWR VPWR sky130_fd_sc_hd__fill_1
XFILLER_54_645 VGND VGND VPWR VPWR sky130_fd_sc_hd__decap_3
XFILLER_26_336 VGND VGND VPWR VPWR sky130_fd_sc_hd__decap_3
XFILLER_121_15 VGND VGND VPWR VPWR sky130_fd_sc_hd__decap_3
XFILLER_54_678 VGND VGND VPWR VPWR sky130_fd_sc_hd__decap_3
XFILLER_121_48 VGND VGND VPWR VPWR sky130_fd_sc_hd__decap_3
X_6956_ _6960_/CLK _6956_/D VGND VGND VPWR VPWR _6956_/Q sky130_fd_sc_hd__dfxtp_2
XFILLER_81_475 VGND VGND VPWR VPWR sky130_fd_sc_hd__decap_3
XFILLER_53_166 VGND VGND VPWR VPWR sky130_fd_sc_hd__fill_2
XFILLER_41_306 VGND VGND VPWR VPWR sky130_fd_sc_hd__decap_3
XFILLER_53_199 VGND VGND VPWR VPWR sky130_fd_sc_hd__decap_3
XFILLER_34_380 VGND VGND VPWR VPWR sky130_fd_sc_hd__decap_3
X_6887_ _7405_/CLK _6887_/D VGND VGND VPWR VPWR _6887_/Q sky130_fd_sc_hd__dfxtp_2
XFILLER_22_542 VGND VGND VPWR VPWR sky130_fd_sc_hd__decap_3
XFILLER_14_46 VGND VGND VPWR VPWR sky130_fd_sc_hd__decap_3
XFILLER_10_704 VGND VGND VPWR VPWR sky130_fd_sc_hd__decap_3
XPHY_EDGE_ROW_40_Right_40 VGND VGND VPWR VPWR sky130_fd_sc_hd__decap_3
XTAP_TAPCELL_ROW_62_1067 VGND VPWR sky130_fd_sc_hd__tapvpwrvgnd_1
XTAP_TAPCELL_ROW_62_1078 VGND VPWR sky130_fd_sc_hd__tapvpwrvgnd_1
XFILLER_22_575 VGND VGND VPWR VPWR sky130_fd_sc_hd__decap_3
XTAP_TAPCELL_ROW_118_1801 VGND VPWR sky130_fd_sc_hd__tapvpwrvgnd_1
XFILLER_6_719 VGND VGND VPWR VPWR sky130_fd_sc_hd__decap_3
XFILLER_108_625 VGND VGND VPWR VPWR sky130_fd_sc_hd__decap_3
XFILLER_108_669 VGND VGND VPWR VPWR sky130_fd_sc_hd__decap_3
XFILLER_107_146 VGND VGND VPWR VPWR sky130_fd_sc_hd__decap_3
XFILLER_30_67 VGND VGND VPWR VPWR sky130_fd_sc_hd__decap_3
XFILLER_30_78 VGND VGND VPWR VPWR sky130_fd_sc_hd__decap_3
XFILLER_123_617 VGND VGND VPWR VPWR sky130_fd_sc_hd__decap_3
Xhold760 _6858_/Q VGND VGND VPWR VPWR _6858_/D sky130_fd_sc_hd__dlygate4sd3_1
Xhold771 _6727_/Q VGND VGND VPWR VPWR _6727_/D sky130_fd_sc_hd__dlygate4sd3_1
Xhold782 _6815_/Q VGND VGND VPWR VPWR _6815_/D sky130_fd_sc_hd__dlygate4sd3_1
XFILLER_122_138 VGND VGND VPWR VPWR sky130_fd_sc_hd__fill_2
Xhold793 _6929_/Q VGND VGND VPWR VPWR _6929_/D sky130_fd_sc_hd__dlygate4sd3_1
XFILLER_89_553 VGND VGND VPWR VPWR sky130_fd_sc_hd__decap_3
XFILLER_89_564 VGND VGND VPWR VPWR sky130_fd_sc_hd__decap_3
XFILLER_77_715 VGND VGND VPWR VPWR sky130_fd_sc_hd__decap_3
XFILLER_103_352 VGND VGND VPWR VPWR sky130_fd_sc_hd__decap_3
XFILLER_89_597 VGND VGND VPWR VPWR sky130_fd_sc_hd__decap_3
XFILLER_76_225 VGND VGND VPWR VPWR sky130_fd_sc_hd__decap_3
XFILLER_103_396 VGND VGND VPWR VPWR sky130_fd_sc_hd__decap_3
XFILLER_92_707 VGND VGND VPWR VPWR sky130_fd_sc_hd__decap_3
XFILLER_45_601 VGND VGND VPWR VPWR sky130_fd_sc_hd__decap_3
XFILLER_91_228 VGND VGND VPWR VPWR sky130_fd_sc_hd__decap_3
XFILLER_45_623 VGND VGND VPWR VPWR sky130_fd_sc_hd__decap_3
XFILLER_29_185 VGND VGND VPWR VPWR sky130_fd_sc_hd__fill_2
XFILLER_45_656 VGND VGND VPWR VPWR sky130_fd_sc_hd__decap_3
XFILLER_17_358 VGND VGND VPWR VPWR sky130_fd_sc_hd__decap_3
XFILLER_32_306 VGND VGND VPWR VPWR sky130_fd_sc_hd__fill_2
XTAP_TAPCELL_ROW_43_824 VGND VPWR sky130_fd_sc_hd__tapvpwrvgnd_1
XFILLER_60_637 VGND VGND VPWR VPWR sky130_fd_sc_hd__decap_3
XFILLER_60_648 VGND VGND VPWR VPWR sky130_fd_sc_hd__decap_3
XFILLER_25_380 VGND VGND VPWR VPWR sky130_fd_sc_hd__decap_3
XFILLER_71_30 VGND VGND VPWR VPWR sky130_fd_sc_hd__decap_3
XFILLER_13_564 VGND VGND VPWR VPWR sky130_fd_sc_hd__decap_3
XFILLER_9_535 VGND VGND VPWR VPWR sky130_fd_sc_hd__decap_3
XFILLER_13_597 VGND VGND VPWR VPWR sky130_fd_sc_hd__decap_3
XTAP_TAPCELL_ROW_23_570 VGND VPWR sky130_fd_sc_hd__tapvpwrvgnd_1
XFILLER_9_579 VGND VGND VPWR VPWR sky130_fd_sc_hd__decap_3
XFILLER_99_317 VGND VGND VPWR VPWR sky130_fd_sc_hd__fill_1
XFILLER_4_251 VGND VGND VPWR VPWR sky130_fd_sc_hd__fill_1
XFILLER_114_628 VGND VGND VPWR VPWR sky130_fd_sc_hd__decap_3
XFILLER_99_328 VGND VGND VPWR VPWR sky130_fd_sc_hd__decap_3
XFILLER_4_262 VGND VGND VPWR VPWR sky130_fd_sc_hd__decap_3
XFILLER_113_116 VGND VGND VPWR VPWR sky130_fd_sc_hd__decap_3
XFILLER_107_691 VGND VGND VPWR VPWR sky130_fd_sc_hd__decap_3
XFILLER_68_704 VGND VGND VPWR VPWR sky130_fd_sc_hd__decap_3
XFILLER_122_672 VGND VGND VPWR VPWR sky130_fd_sc_hd__decap_3
XFILLER_67_214 VGND VGND VPWR VPWR sky130_fd_sc_hd__decap_3
XFILLER_96_71 VGND VGND VPWR VPWR sky130_fd_sc_hd__decap_3
XFILLER_67_225 VGND VGND VPWR VPWR sky130_fd_sc_hd__fill_2
XFILLER_67_236 VGND VGND VPWR VPWR sky130_fd_sc_hd__decap_3
XFILLER_95_556 VGND VGND VPWR VPWR sky130_fd_sc_hd__decap_3
XFILLER_121_193 VGND VGND VPWR VPWR sky130_fd_sc_hd__decap_3
XFILLER_95_567 VGND VGND VPWR VPWR sky130_fd_sc_hd__decap_3
XFILLER_83_718 VGND VGND VPWR VPWR sky130_fd_sc_hd__decap_3
XFILLER_67_269 VGND VGND VPWR VPWR sky130_fd_sc_hd__decap_3
XFILLER_83_729 VGND VGND VPWR VPWR sky130_fd_sc_hd__decap_3
XFILLER_82_206 VGND VGND VPWR VPWR sky130_fd_sc_hd__decap_3
XFILLER_36_601 VGND VGND VPWR VPWR sky130_fd_sc_hd__decap_3
XFILLER_48_472 VGND VGND VPWR VPWR sky130_fd_sc_hd__decap_3
XFILLER_36_634 VGND VGND VPWR VPWR sky130_fd_sc_hd__decap_3
XFILLER_63_431 VGND VGND VPWR VPWR sky130_fd_sc_hd__decap_3
XFILLER_36_645 VGND VGND VPWR VPWR sky130_fd_sc_hd__decap_3
XFILLER_35_122 VGND VGND VPWR VPWR sky130_fd_sc_hd__decap_3
X_6810_ _6967_/CLK _6810_/D VGND VGND VPWR VPWR _6810_/Q sky130_fd_sc_hd__dfxtp_2
Xplace420 _3977_/S VGND VGND VPWR VPWR _3987_/S sky130_fd_sc_hd__buf_2
XFILLER_36_678 VGND VGND VPWR VPWR sky130_fd_sc_hd__decap_3
Xplace431 _3371_/Y VGND VGND VPWR VPWR _3977_/S sky130_fd_sc_hd__buf_2
XFILLER_63_464 VGND VGND VPWR VPWR sky130_fd_sc_hd__decap_3
XFILLER_51_604 VGND VGND VPWR VPWR sky130_fd_sc_hd__decap_3
Xplace442 _4667_/B VGND VGND VPWR VPWR _5634_/B sky130_fd_sc_hd__buf_2
XFILLER_51_626 VGND VGND VPWR VPWR sky130_fd_sc_hd__decap_3
XFILLER_23_317 VGND VGND VPWR VPWR sky130_fd_sc_hd__decap_3
Xplace453 _3386_/A VGND VGND VPWR VPWR _5129_/A sky130_fd_sc_hd__buf_2
XFILLER_90_272 VGND VGND VPWR VPWR sky130_fd_sc_hd__decap_3
XFILLER_63_497 VGND VGND VPWR VPWR sky130_fd_sc_hd__decap_3
X_6741_ clkload4/A _6741_/D VGND VGND VPWR VPWR _6741_/Q sky130_fd_sc_hd__dfxtp_2
XFILLER_51_659 VGND VGND VPWR VPWR sky130_fd_sc_hd__decap_3
XFILLER_16_391 VGND VGND VPWR VPWR sky130_fd_sc_hd__decap_3
XFILLER_50_169 VGND VGND VPWR VPWR sky130_fd_sc_hd__decap_3
X_3884_ _6824_/Q _3884_/A2 _3884_/B1 _6809_/Q _3883_/X VGND VGND VPWR VPWR _3884_/X
+ sky130_fd_sc_hd__a221o_2
X_6672_ _6672_/A VGND VGND VPWR VPWR _6672_/Y sky130_fd_sc_hd__inv_2
XFILLER_31_383 VGND VGND VPWR VPWR sky130_fd_sc_hd__decap_3
XFILLER_117_411 VGND VGND VPWR VPWR sky130_fd_sc_hd__decap_3
X_4505_ _4505_/A0 _7295_/Q _4505_/S VGND VGND VPWR VPWR _7327_/D sky130_fd_sc_hd__mux2_2
XFILLER_105_606 VGND VGND VPWR VPWR sky130_fd_sc_hd__decap_3
XFILLER_105_617 VGND VGND VPWR VPWR sky130_fd_sc_hd__decap_3
XFILLER_6_80 VGND VGND VPWR VPWR sky130_fd_sc_hd__decap_3
XFILLER_117_488 VGND VGND VPWR VPWR sky130_fd_sc_hd__decap_3
X_4436_ _7303_/Q _4914_/S _4436_/B1 _7175_/Q _4435_/X VGND VGND VPWR VPWR _4436_/X
+ sky130_fd_sc_hd__a221o_2
X_7224_ _7354_/CLK _7224_/D _6504_/Y VGND VGND VPWR VPWR _7224_/Q sky130_fd_sc_hd__dfrtp_2
XTAP_TAPCELL_ROW_113_1731 VGND VPWR sky130_fd_sc_hd__tapvpwrvgnd_1
XTAP_TAPCELL_ROW_113_1742 VGND VPWR sky130_fd_sc_hd__tapvpwrvgnd_1
XFILLER_116_26 VGND VGND VPWR VPWR sky130_fd_sc_hd__fill_2
X_4367_ _4367_/A _4367_/B _4367_/C VGND VGND VPWR VPWR _5054_/A sky130_fd_sc_hd__and3_2
X_7155_ _7352_/CLK _7155_/D _6435_/Y VGND VGND VPWR VPWR _7155_/Q sky130_fd_sc_hd__dfrtp_2
XFILLER_113_650 VGND VGND VPWR VPWR sky130_fd_sc_hd__decap_3
XFILLER_59_715 VGND VGND VPWR VPWR sky130_fd_sc_hd__decap_3
XFILLER_116_59 VGND VGND VPWR VPWR sky130_fd_sc_hd__decap_3
XFILLER_98_372 VGND VGND VPWR VPWR sky130_fd_sc_hd__decap_3
X_3318_ _5667_/A _3332_/B VGND VGND VPWR VPWR _5647_/B sky130_fd_sc_hd__nand2_2
XFILLER_113_694 VGND VGND VPWR VPWR sky130_fd_sc_hd__decap_3
X_7086_ _7399_/CLK _7086_/D _6366_/Y VGND VGND VPWR VPWR _7086_/Q sky130_fd_sc_hd__dfrtp_2
X_4298_ _3620_/C _4292_/X _4293_/X _4297_/Y VGND VGND VPWR VPWR _4298_/X sky130_fd_sc_hd__a211o_2
XFILLER_58_236 VGND VGND VPWR VPWR sky130_fd_sc_hd__decap_3
XFILLER_74_707 VGND VGND VPWR VPWR sky130_fd_sc_hd__decap_3
XFILLER_86_589 VGND VGND VPWR VPWR sky130_fd_sc_hd__decap_3
XFILLER_73_206 VGND VGND VPWR VPWR sky130_fd_sc_hd__decap_3
XFILLER_73_228 VGND VGND VPWR VPWR sky130_fd_sc_hd__decap_3
XFILLER_39_483 VGND VGND VPWR VPWR sky130_fd_sc_hd__decap_3
XFILLER_27_623 VGND VGND VPWR VPWR sky130_fd_sc_hd__decap_3
XFILLER_26_111 VGND VGND VPWR VPWR sky130_fd_sc_hd__decap_3
XFILLER_66_280 VGND VGND VPWR VPWR sky130_fd_sc_hd__decap_3
XFILLER_92_29 VGND VGND VPWR VPWR sky130_fd_sc_hd__fill_2
XFILLER_27_656 VGND VGND VPWR VPWR sky130_fd_sc_hd__decap_3
XFILLER_26_133 VGND VGND VPWR VPWR sky130_fd_sc_hd__decap_3
XFILLER_26_144 VGND VGND VPWR VPWR sky130_fd_sc_hd__decap_3
XTAP_TAPCELL_ROW_1_276 VGND VPWR sky130_fd_sc_hd__tapvpwrvgnd_1
XFILLER_42_604 VGND VGND VPWR VPWR sky130_fd_sc_hd__decap_3
XFILLER_81_272 VGND VGND VPWR VPWR sky130_fd_sc_hd__decap_3
XFILLER_42_637 VGND VGND VPWR VPWR sky130_fd_sc_hd__decap_3
XFILLER_42_648 VGND VGND VPWR VPWR sky130_fd_sc_hd__decap_3
X_6939_ _7405_/CLK _6939_/D VGND VGND VPWR VPWR _6939_/Q sky130_fd_sc_hd__dfxtp_2
XFILLER_25_89 VGND VGND VPWR VPWR sky130_fd_sc_hd__decap_3
XFILLER_41_169 VGND VGND VPWR VPWR sky130_fd_sc_hd__decap_3
XFILLER_22_350 VGND VGND VPWR VPWR sky130_fd_sc_hd__decap_3
XFILLER_50_681 VGND VGND VPWR VPWR sky130_fd_sc_hd__decap_3
XFILLER_41_11 VGND VGND VPWR VPWR sky130_fd_sc_hd__fill_1
XFILLER_10_545 VGND VGND VPWR VPWR sky130_fd_sc_hd__decap_3
XFILLER_6_527 VGND VGND VPWR VPWR sky130_fd_sc_hd__fill_2
XFILLER_41_66 VGND VGND VPWR VPWR sky130_fd_sc_hd__decap_3
XFILLER_10_578 VGND VGND VPWR VPWR sky130_fd_sc_hd__decap_3
XFILLER_108_411 VGND VGND VPWR VPWR sky130_fd_sc_hd__decap_3
XFILLER_10_589 VGND VGND VPWR VPWR sky130_fd_sc_hd__decap_3
XFILLER_41_99 VGND VGND VPWR VPWR sky130_fd_sc_hd__decap_3
XFILLER_108_477 VGND VGND VPWR VPWR sky130_fd_sc_hd__decap_3
XTAP_TAPCELL_ROW_75_1236 VGND VPWR sky130_fd_sc_hd__tapvpwrvgnd_1
XTAP_TAPCELL_ROW_75_1247 VGND VPWR sky130_fd_sc_hd__tapvpwrvgnd_1
XFILLER_2_722 VGND VGND VPWR VPWR sky130_fd_sc_hd__decap_3
XFILLER_111_609 VGND VGND VPWR VPWR sky130_fd_sc_hd__decap_3
Xhold590 _6748_/Q VGND VGND VPWR VPWR _6748_/D sky130_fd_sc_hd__dlygate4sd3_1
XFILLER_96_309 VGND VGND VPWR VPWR sky130_fd_sc_hd__decap_3
XTAP_TAPCELL_ROW_9_387 VGND VPWR sky130_fd_sc_hd__tapvpwrvgnd_1
XFILLER_104_672 VGND VGND VPWR VPWR sky130_fd_sc_hd__decap_3
XFILLER_49_214 VGND VGND VPWR VPWR sky130_fd_sc_hd__decap_3
XFILLER_1_276 VGND VGND VPWR VPWR sky130_fd_sc_hd__decap_3
XFILLER_49_225 VGND VGND VPWR VPWR sky130_fd_sc_hd__decap_3
XFILLER_2_27 VGND VGND VPWR VPWR sky130_fd_sc_hd__fill_1
XFILLER_1_287 VGND VGND VPWR VPWR sky130_fd_sc_hd__decap_3
XFILLER_77_556 VGND VGND VPWR VPWR sky130_fd_sc_hd__fill_1
XFILLER_49_258 VGND VGND VPWR VPWR sky130_fd_sc_hd__decap_3
XFILLER_66_41 VGND VGND VPWR VPWR sky130_fd_sc_hd__decap_3
XFILLER_65_718 VGND VGND VPWR VPWR sky130_fd_sc_hd__decap_3
XFILLER_49_269 VGND VGND VPWR VPWR sky130_fd_sc_hd__decap_3
XFILLER_66_52 VGND VGND VPWR VPWR sky130_fd_sc_hd__decap_3
XFILLER_65_729 VGND VGND VPWR VPWR sky130_fd_sc_hd__decap_3
XFILLER_64_206 VGND VGND VPWR VPWR sky130_fd_sc_hd__decap_3
XFILLER_18_601 VGND VGND VPWR VPWR sky130_fd_sc_hd__decap_3
XFILLER_64_239 VGND VGND VPWR VPWR sky130_fd_sc_hd__decap_3
XFILLER_18_634 VGND VGND VPWR VPWR sky130_fd_sc_hd__decap_3
XFILLER_92_559 VGND VGND VPWR VPWR sky130_fd_sc_hd__decap_3
XFILLER_18_645 VGND VGND VPWR VPWR sky130_fd_sc_hd__decap_3
XFILLER_57_291 VGND VGND VPWR VPWR sky130_fd_sc_hd__decap_3
XFILLER_45_442 VGND VGND VPWR VPWR sky130_fd_sc_hd__decap_3
XFILLER_18_678 VGND VGND VPWR VPWR sky130_fd_sc_hd__decap_3
XFILLER_60_401 VGND VGND VPWR VPWR sky130_fd_sc_hd__decap_3
XFILLER_122_80 VGND VGND VPWR VPWR sky130_fd_sc_hd__decap_3
XTAP_TAPCELL_ROW_86_1387 VGND VPWR sky130_fd_sc_hd__tapvpwrvgnd_1
XFILLER_72_272 VGND VGND VPWR VPWR sky130_fd_sc_hd__fill_2
XFILLER_33_626 VGND VGND VPWR VPWR sky130_fd_sc_hd__decap_3
XFILLER_122_91 VGND VGND VPWR VPWR sky130_fd_sc_hd__decap_3
XTAP_TAPCELL_ROW_56_993 VGND VPWR sky130_fd_sc_hd__tapvpwrvgnd_1
XFILLER_72_294 VGND VGND VPWR VPWR sky130_fd_sc_hd__decap_3
XFILLER_33_659 VGND VGND VPWR VPWR sky130_fd_sc_hd__decap_3
XFILLER_32_158 VGND VGND VPWR VPWR sky130_fd_sc_hd__decap_3
XFILLER_13_350 VGND VGND VPWR VPWR sky130_fd_sc_hd__decap_3
XFILLER_13_383 VGND VGND VPWR VPWR sky130_fd_sc_hd__decap_3
XFILLER_119_709 VGND VGND VPWR VPWR sky130_fd_sc_hd__decap_3
XFILLER_9_365 VGND VGND VPWR VPWR sky130_fd_sc_hd__decap_3
XFILLER_70_6 VGND VGND VPWR VPWR sky130_fd_sc_hd__decap_3
XFILLER_9_387 VGND VGND VPWR VPWR sky130_fd_sc_hd__decap_3
X_5270_ _5270_/A0 _5040_/X _5292_/S VGND VGND VPWR VPWR _7195_/D sky130_fd_sc_hd__mux2_2
XFILLER_5_582 VGND VGND VPWR VPWR sky130_fd_sc_hd__decap_3
XFILLER_49_3 VGND VGND VPWR VPWR sky130_fd_sc_hd__fill_1
XFILLER_114_458 VGND VGND VPWR VPWR sky130_fd_sc_hd__decap_3
X_4221_ _7228_/Q _4414_/A2 _4244_/B _7041_/Q _4220_/X VGND VGND VPWR VPWR _4221_/X
+ sky130_fd_sc_hd__a221o_2
XFILLER_99_169 VGND VGND VPWR VPWR sky130_fd_sc_hd__decap_3
XFILLER_68_501 VGND VGND VPWR VPWR sky130_fd_sc_hd__fill_1
XFILLER_68_512 VGND VGND VPWR VPWR sky130_fd_sc_hd__decap_3
XFILLER_101_119 VGND VGND VPWR VPWR sky130_fd_sc_hd__decap_3
X_4152_ _7106_/Q _4351_/A2 _4267_/A2 _7138_/Q VGND VGND VPWR VPWR _4152_/X sky130_fd_sc_hd__a22o_2
XFILLER_122_480 VGND VGND VPWR VPWR sky130_fd_sc_hd__decap_3
XFILLER_110_631 VGND VGND VPWR VPWR sky130_fd_sc_hd__decap_3
XFILLER_56_707 VGND VGND VPWR VPWR sky130_fd_sc_hd__decap_3
X_4083_ _7366_/Q _4419_/B1 _4459_/C1 _7174_/Q VGND VGND VPWR VPWR _4083_/X sky130_fd_sc_hd__a22o_2
XFILLER_68_589 VGND VGND VPWR VPWR sky130_fd_sc_hd__fill_1
XFILLER_110_675 VGND VGND VPWR VPWR sky130_fd_sc_hd__decap_3
XFILLER_55_228 VGND VGND VPWR VPWR sky130_fd_sc_hd__decap_3
XFILLER_36_464 VGND VGND VPWR VPWR sky130_fd_sc_hd__decap_3
XFILLER_24_604 VGND VGND VPWR VPWR sky130_fd_sc_hd__decap_3
XFILLER_91_570 VGND VGND VPWR VPWR sky130_fd_sc_hd__decap_3
XFILLER_36_486 VGND VGND VPWR VPWR sky130_fd_sc_hd__fill_1
XFILLER_24_637 VGND VGND VPWR VPWR sky130_fd_sc_hd__decap_3
XFILLER_51_423 VGND VGND VPWR VPWR sky130_fd_sc_hd__decap_3
XFILLER_24_648 VGND VGND VPWR VPWR sky130_fd_sc_hd__decap_3
XFILLER_51_445 VGND VGND VPWR VPWR sky130_fd_sc_hd__decap_3
X_4985_ _4620_/A _5032_/A _5031_/B _4630_/X VGND VGND VPWR VPWR _5003_/B sky130_fd_sc_hd__a31o_2
Xplace272 _5660_/A VGND VGND VPWR VPWR _3923_/A1 sky130_fd_sc_hd__buf_2
Xplace283 _3888_/A2 VGND VGND VPWR VPWR _3884_/A2 sky130_fd_sc_hd__buf_2
XFILLER_51_467 VGND VGND VPWR VPWR sky130_fd_sc_hd__decap_3
XFILLER_23_158 VGND VGND VPWR VPWR sky130_fd_sc_hd__decap_3
Xplace294 _3884_/B1 VGND VGND VPWR VPWR _3925_/A2 sky130_fd_sc_hd__buf_2
X_6724_ clkload5/A _6724_/D VGND VGND VPWR VPWR _6724_/Q sky130_fd_sc_hd__dfxtp_2
XFILLER_23_169 VGND VGND VPWR VPWR sky130_fd_sc_hd__decap_3
XFILLER_32_681 VGND VGND VPWR VPWR sky130_fd_sc_hd__decap_3
X_6655_ _6664_/A VGND VGND VPWR VPWR _6655_/Y sky130_fd_sc_hd__inv_2
X_3867_ _3629_/Y _3866_/X _5151_/A VGND VGND VPWR VPWR _3867_/X sky130_fd_sc_hd__o21a_2
XFILLER_118_731 VGND VGND VPWR VPWR sky130_fd_sc_hd__decap_3
X_6586_ _6618_/A VGND VGND VPWR VPWR _6586_/Y sky130_fd_sc_hd__inv_2
X_3798_ _6738_/Q _3891_/A2 _3878_/B1 _6744_/Q _3797_/X VGND VGND VPWR VPWR _3798_/X
+ sky130_fd_sc_hd__a221o_2
XFILLER_3_508 VGND VGND VPWR VPWR sky130_fd_sc_hd__decap_3
XFILLER_87_18 VGND VGND VPWR VPWR sky130_fd_sc_hd__decap_3
XFILLER_2_9 VGND VGND VPWR VPWR sky130_fd_sc_hd__decap_3
X_7207_ _7399_/CLK _7207_/D _6487_/Y VGND VGND VPWR VPWR _7207_/Q sky130_fd_sc_hd__dfrtp_2
XFILLER_78_309 VGND VGND VPWR VPWR sky130_fd_sc_hd__decap_3
X_4419_ _7304_/Q _4497_/S _4419_/B1 _7368_/Q _4429_/C1 VGND VGND VPWR VPWR _4419_/X
+ sky130_fd_sc_hd__a221o_2
XTAP_TAPCELL_ROW_6_346 VGND VPWR sky130_fd_sc_hd__tapvpwrvgnd_1
X_7138_ _7360_/CLK _7138_/D _6418_/Y VGND VGND VPWR VPWR _7138_/Q sky130_fd_sc_hd__dfrtp_2
XFILLER_113_480 VGND VGND VPWR VPWR sky130_fd_sc_hd__decap_3
XFILLER_101_620 VGND VGND VPWR VPWR sky130_fd_sc_hd__decap_3
XFILLER_98_191 VGND VGND VPWR VPWR sky130_fd_sc_hd__decap_3
XFILLER_101_653 VGND VGND VPWR VPWR sky130_fd_sc_hd__decap_3
XTAP_TAPCELL_ROW_70_1177 VGND VPWR sky130_fd_sc_hd__tapvpwrvgnd_1
XFILLER_47_718 VGND VGND VPWR VPWR sky130_fd_sc_hd__decap_3
XFILLER_100_141 VGND VGND VPWR VPWR sky130_fd_sc_hd__fill_1
X_7069_ _7392_/CLK _7069_/D _6349_/Y VGND VGND VPWR VPWR _7069_/Q sky130_fd_sc_hd__dfrtp_2
XFILLER_47_729 VGND VGND VPWR VPWR sky130_fd_sc_hd__decap_3
XFILLER_46_228 VGND VGND VPWR VPWR sky130_fd_sc_hd__decap_3
XFILLER_101_697 VGND VGND VPWR VPWR sky130_fd_sc_hd__decap_3
XFILLER_100_174 VGND VGND VPWR VPWR sky130_fd_sc_hd__decap_3
XFILLER_61_209 VGND VGND VPWR VPWR sky130_fd_sc_hd__decap_3
XFILLER_15_615 VGND VGND VPWR VPWR sky130_fd_sc_hd__fill_1
XFILLER_70_710 VGND VGND VPWR VPWR sky130_fd_sc_hd__decap_3
XFILLER_15_626 VGND VGND VPWR VPWR sky130_fd_sc_hd__decap_3
XFILLER_54_272 VGND VGND VPWR VPWR sky130_fd_sc_hd__decap_3
XFILLER_36_88 VGND VGND VPWR VPWR sky130_fd_sc_hd__decap_3
XFILLER_82_592 VGND VGND VPWR VPWR sky130_fd_sc_hd__decap_3
XFILLER_15_659 VGND VGND VPWR VPWR sky130_fd_sc_hd__decap_3
XTAP_TAPCELL_ROW_53_952 VGND VPWR sky130_fd_sc_hd__tapvpwrvgnd_1
XFILLER_30_607 VGND VGND VPWR VPWR sky130_fd_sc_hd__decap_3
XFILLER_52_32 VGND VGND VPWR VPWR sky130_fd_sc_hd__fill_2
XFILLER_10_331 VGND VGND VPWR VPWR sky130_fd_sc_hd__decap_3
XFILLER_6_368 VGND VGND VPWR VPWR sky130_fd_sc_hd__fill_1
XFILLER_108_285 VGND VGND VPWR VPWR sky130_fd_sc_hd__decap_3
XFILLER_123_233 VGND VGND VPWR VPWR sky130_fd_sc_hd__decap_3
XFILLER_69_309 VGND VGND VPWR VPWR sky130_fd_sc_hd__decap_3
XFILLER_97_629 VGND VGND VPWR VPWR sky130_fd_sc_hd__decap_3
XFILLER_2_563 VGND VGND VPWR VPWR sky130_fd_sc_hd__decap_3
XFILLER_123_277 VGND VGND VPWR VPWR sky130_fd_sc_hd__decap_3
XFILLER_123_299 VGND VGND VPWR VPWR sky130_fd_sc_hd__decap_3
XFILLER_111_439 VGND VGND VPWR VPWR sky130_fd_sc_hd__decap_3
XFILLER_77_320 VGND VGND VPWR VPWR sky130_fd_sc_hd__decap_3
XFILLER_89_180 VGND VGND VPWR VPWR sky130_fd_sc_hd__decap_3
XFILLER_38_707 VGND VGND VPWR VPWR sky130_fd_sc_hd__decap_3
XFILLER_77_353 VGND VGND VPWR VPWR sky130_fd_sc_hd__decap_3
XTAP_TAPCELL_ROW_88_1405 VGND VPWR sky130_fd_sc_hd__tapvpwrvgnd_1
XFILLER_77_95 VGND VGND VPWR VPWR sky130_fd_sc_hd__fill_2
XTAP_TAPCELL_ROW_88_1416 VGND VPWR sky130_fd_sc_hd__tapvpwrvgnd_1
XFILLER_65_526 VGND VGND VPWR VPWR sky130_fd_sc_hd__decap_3
XFILLER_37_228 VGND VGND VPWR VPWR sky130_fd_sc_hd__fill_2
XFILLER_92_334 VGND VGND VPWR VPWR sky130_fd_sc_hd__decap_3
XFILLER_65_548 VGND VGND VPWR VPWR sky130_fd_sc_hd__decap_3
XFILLER_18_442 VGND VGND VPWR VPWR sky130_fd_sc_hd__decap_3
XFILLER_92_389 VGND VGND VPWR VPWR sky130_fd_sc_hd__decap_3
XFILLER_45_250 VGND VGND VPWR VPWR sky130_fd_sc_hd__fill_1
XFILLER_18_475 VGND VGND VPWR VPWR sky130_fd_sc_hd__fill_1
XFILLER_61_721 VGND VGND VPWR VPWR sky130_fd_sc_hd__decap_3
XFILLER_61_732 VGND VGND VPWR VPWR sky130_fd_sc_hd__decap_3
XFILLER_60_231 VGND VGND VPWR VPWR sky130_fd_sc_hd__decap_3
XFILLER_60_253 VGND VGND VPWR VPWR sky130_fd_sc_hd__decap_3
XFILLER_21_607 VGND VGND VPWR VPWR sky130_fd_sc_hd__decap_3
XFILLER_21_629 VGND VGND VPWR VPWR sky130_fd_sc_hd__decap_3
X_4770_ _4799_/A _3692_/X _5663_/A _4791_/C1 VGND VGND VPWR VPWR _4770_/X sky130_fd_sc_hd__a211o_2
XFILLER_14_681 VGND VGND VPWR VPWR sky130_fd_sc_hd__decap_3
X_3721_ _6863_/Q _3889_/A2 _3884_/B1 _6855_/Q _3720_/X VGND VGND VPWR VPWR _3721_/X
+ sky130_fd_sc_hd__a221o_2
XFILLER_119_517 VGND VGND VPWR VPWR sky130_fd_sc_hd__decap_3
XTAP_TAPCELL_ROW_31_668 VGND VPWR sky130_fd_sc_hd__tapvpwrvgnd_1
XTAP_TAPCELL_ROW_99_1556 VGND VPWR sky130_fd_sc_hd__tapvpwrvgnd_1
X_6440_ _6632_/A VGND VGND VPWR VPWR _6440_/Y sky130_fd_sc_hd__inv_2
X_3583_ _3583_/A _3583_/B _3583_/C VGND VGND VPWR VPWR _3583_/X sky130_fd_sc_hd__or3_4
X_6371_ _6566_/A VGND VGND VPWR VPWR _6371_/Y sky130_fd_sc_hd__inv_2
XFILLER_115_712 VGND VGND VPWR VPWR sky130_fd_sc_hd__decap_3
XFILLER_114_200 VGND VGND VPWR VPWR sky130_fd_sc_hd__decap_3
XFILLER_88_607 VGND VGND VPWR VPWR sky130_fd_sc_hd__decap_3
XTAP_TAPCELL_ROW_110_1701 VGND VPWR sky130_fd_sc_hd__tapvpwrvgnd_1
X_5253_ _5253_/A0 _4913_/X _5258_/S VGND VGND VPWR VPWR _7203_/D sky130_fd_sc_hd__mux2_2
XFILLER_87_106 VGND VGND VPWR VPWR sky130_fd_sc_hd__decap_3
XFILLER_87_128 VGND VGND VPWR VPWR sky130_fd_sc_hd__decap_3
X_4204_ _4936_/A _4201_/X _4203_/X VGND VGND VPWR VPWR _4204_/Y sky130_fd_sc_hd__o21bai_2
XFILLER_102_439 VGND VGND VPWR VPWR sky130_fd_sc_hd__fill_2
X_5184_ _5184_/A _5200_/B VGND VGND VPWR VPWR _7236_/D sky130_fd_sc_hd__and2_2
XFILLER_96_640 VGND VGND VPWR VPWR sky130_fd_sc_hd__decap_3
XFILLER_96_651 VGND VGND VPWR VPWR sky130_fd_sc_hd__decap_3
XTAP_TAPCELL_ROW_3_305 VGND VPWR sky130_fd_sc_hd__tapvpwrvgnd_1
X_4135_ _7107_/Q _4351_/A2 _4267_/A2 _7139_/Q VGND VGND VPWR VPWR _4135_/X sky130_fd_sc_hd__a22o_2
XFILLER_29_718 VGND VGND VPWR VPWR sky130_fd_sc_hd__decap_3
XFILLER_110_450 VGND VGND VPWR VPWR sky130_fd_sc_hd__fill_1
XFILLER_95_150 VGND VGND VPWR VPWR sky130_fd_sc_hd__decap_3
XFILLER_29_729 VGND VGND VPWR VPWR sky130_fd_sc_hd__decap_3
XFILLER_96_684 VGND VGND VPWR VPWR sky130_fd_sc_hd__decap_3
XFILLER_28_206 VGND VGND VPWR VPWR sky130_fd_sc_hd__decap_3
XFILLER_68_397 VGND VGND VPWR VPWR sky130_fd_sc_hd__fill_2
XFILLER_28_239 VGND VGND VPWR VPWR sky130_fd_sc_hd__decap_3
XFILLER_113_27 VGND VGND VPWR VPWR sky130_fd_sc_hd__decap_3
X_4066_ _4062_/X _4065_/X _4425_/A VGND VGND VPWR VPWR _4082_/A sky130_fd_sc_hd__o21a_2
XFILLER_95_194 VGND VGND VPWR VPWR sky130_fd_sc_hd__decap_3
XTAP_TAPCELL_ROW_39_768 VGND VPWR sky130_fd_sc_hd__tapvpwrvgnd_1
XTAP_TAPCELL_ROW_39_779 VGND VPWR sky130_fd_sc_hd__tapvpwrvgnd_1
XTAP_TAPCELL_ROW_108_1674 VGND VPWR sky130_fd_sc_hd__tapvpwrvgnd_1
XFILLER_52_710 VGND VGND VPWR VPWR sky130_fd_sc_hd__decap_3
XFILLER_24_401 VGND VGND VPWR VPWR sky130_fd_sc_hd__decap_3
XFILLER_64_581 VGND VGND VPWR VPWR sky130_fd_sc_hd__decap_3
XFILLER_64_592 VGND VGND VPWR VPWR sky130_fd_sc_hd__decap_3
XTAP_TAPCELL_ROW_121_1841 VGND VPWR sky130_fd_sc_hd__tapvpwrvgnd_1
XFILLER_12_607 VGND VGND VPWR VPWR sky130_fd_sc_hd__decap_3
XTAP_TAPCELL_ROW_50_911 VGND VPWR sky130_fd_sc_hd__tapvpwrvgnd_1
XFILLER_11_106 VGND VGND VPWR VPWR sky130_fd_sc_hd__decap_3
XTAP_TAPCELL_ROW_50_922 VGND VPWR sky130_fd_sc_hd__tapvpwrvgnd_1
X_4968_ _4968_/A _4967_/B VGND VGND VPWR VPWR _4968_/Y sky130_fd_sc_hd__nor2b_2
X_6707_ _7405_/CLK _6707_/D VGND VGND VPWR VPWR _6707_/Q sky130_fd_sc_hd__dfxtp_2
X_3919_ _3682_/A _3918_/X _4791_/A1 VGND VGND VPWR VPWR _3919_/X sky130_fd_sc_hd__a21o_2
XFILLER_20_640 VGND VGND VPWR VPWR sky130_fd_sc_hd__decap_3
X_4899_ _5040_/S _6998_/D _5656_/B _4898_/X VGND VGND VPWR VPWR _4899_/X sky130_fd_sc_hd__o22a_2
XFILLER_20_651 VGND VGND VPWR VPWR sky130_fd_sc_hd__decap_3
X_6638_ _6638_/A VGND VGND VPWR VPWR _6638_/Y sky130_fd_sc_hd__inv_2
XFILLER_22_57 VGND VGND VPWR VPWR sky130_fd_sc_hd__fill_1
XFILLER_20_684 VGND VGND VPWR VPWR sky130_fd_sc_hd__decap_3
XTAP_TAPCELL_ROW_59_1028 VGND VPWR sky130_fd_sc_hd__tapvpwrvgnd_1
XTAP_TAPCELL_ROW_59_1039 VGND VPWR sky130_fd_sc_hd__tapvpwrvgnd_1
XFILLER_118_6 VGND VGND VPWR VPWR sky130_fd_sc_hd__decap_3
XFILLER_106_701 VGND VGND VPWR VPWR sky130_fd_sc_hd__decap_3
X_6569_ _6569_/A VGND VGND VPWR VPWR _6569_/Y sky130_fd_sc_hd__inv_2
XFILLER_118_572 VGND VGND VPWR VPWR sky130_fd_sc_hd__decap_3
XFILLER_106_734 VGND VGND VPWR VPWR sky130_fd_sc_hd__fill_1
XTAP_TAPCELL_ROW_72_1206 VGND VPWR sky130_fd_sc_hd__tapvpwrvgnd_1
XFILLER_79_629 VGND VGND VPWR VPWR sky130_fd_sc_hd__decap_3
XFILLER_121_715 VGND VGND VPWR VPWR sky130_fd_sc_hd__decap_3
XFILLER_105_266 VGND VGND VPWR VPWR sky130_fd_sc_hd__decap_3
Xoutput470 _5657_/C VGND VGND VPWR VPWR alu_result_out[18] sky130_fd_sc_hd__clkdlybuf4s25_1
XFILLER_78_106 VGND VGND VPWR VPWR sky130_fd_sc_hd__decap_3
Xoutput481 _5663_/A VGND VGND VPWR VPWR alu_result_out[28] sky130_fd_sc_hd__clkdlybuf4s25_1
Xoutput492 _5658_/C VGND VGND VPWR VPWR alu_result_out[9] sky130_fd_sc_hd__clkdlybuf4s25_1
XFILLER_78_139 VGND VGND VPWR VPWR sky130_fd_sc_hd__fill_1
XFILLER_87_662 VGND VGND VPWR VPWR sky130_fd_sc_hd__decap_3
XFILLER_87_673 VGND VGND VPWR VPWR sky130_fd_sc_hd__decap_3
XFILLER_19_206 VGND VGND VPWR VPWR sky130_fd_sc_hd__decap_3
XFILLER_101_461 VGND VGND VPWR VPWR sky130_fd_sc_hd__decap_3
XFILLER_86_172 VGND VGND VPWR VPWR sky130_fd_sc_hd__decap_3
XFILLER_74_312 VGND VGND VPWR VPWR sky130_fd_sc_hd__fill_1
XFILLER_47_54 VGND VGND VPWR VPWR sky130_fd_sc_hd__fill_2
XFILLER_19_228 VGND VGND VPWR VPWR sky130_fd_sc_hd__decap_3
XFILLER_74_345 VGND VGND VPWR VPWR sky130_fd_sc_hd__decap_3
XFILLER_55_570 VGND VGND VPWR VPWR sky130_fd_sc_hd__decap_3
XFILLER_103_60 VGND VGND VPWR VPWR sky130_fd_sc_hd__fill_1
XFILLER_43_721 VGND VGND VPWR VPWR sky130_fd_sc_hd__decap_3
XFILLER_27_272 VGND VGND VPWR VPWR sky130_fd_sc_hd__decap_3
XFILLER_43_732 VGND VGND VPWR VPWR sky130_fd_sc_hd__decap_3
XTAP_TAPCELL_ROW_83_1346 VGND VPWR sky130_fd_sc_hd__tapvpwrvgnd_1
XPHY_EDGE_ROW_69_Right_69 VGND VGND VPWR VPWR sky130_fd_sc_hd__decap_3
XFILLER_42_253 VGND VGND VPWR VPWR sky130_fd_sc_hd__decap_3
XFILLER_15_478 VGND VGND VPWR VPWR sky130_fd_sc_hd__decap_3
XFILLER_30_415 VGND VGND VPWR VPWR sky130_fd_sc_hd__decap_3
XFILLER_70_584 VGND VGND VPWR VPWR sky130_fd_sc_hd__decap_3
XFILLER_70_595 VGND VGND VPWR VPWR sky130_fd_sc_hd__decap_3
XFILLER_7_600 VGND VGND VPWR VPWR sky130_fd_sc_hd__decap_3
XFILLER_11_662 VGND VGND VPWR VPWR sky130_fd_sc_hd__decap_3
XFILLER_11_673 VGND VGND VPWR VPWR sky130_fd_sc_hd__decap_3
XFILLER_10_150 VGND VGND VPWR VPWR sky130_fd_sc_hd__fill_2
XFILLER_7_644 VGND VGND VPWR VPWR sky130_fd_sc_hd__decap_3
Xwire564 _6558_/A VGND VGND VPWR VPWR _6620_/A sky130_fd_sc_hd__buf_2
XFILLER_116_509 VGND VGND VPWR VPWR sky130_fd_sc_hd__decap_3
XFILLER_109_561 VGND VGND VPWR VPWR sky130_fd_sc_hd__decap_3
XFILLER_7_688 VGND VGND VPWR VPWR sky130_fd_sc_hd__decap_3
XFILLER_6_176 VGND VGND VPWR VPWR sky130_fd_sc_hd__fill_1
XFILLER_109_594 VGND VGND VPWR VPWR sky130_fd_sc_hd__decap_3
XPHY_EDGE_ROW_78_Right_78 VGND VGND VPWR VPWR sky130_fd_sc_hd__decap_3
XTAP_TAPCELL_ROW_94_1486 VGND VPWR sky130_fd_sc_hd__tapvpwrvgnd_1
XFILLER_112_704 VGND VGND VPWR VPWR sky130_fd_sc_hd__decap_3
XFILLER_88_72 VGND VGND VPWR VPWR sky130_fd_sc_hd__fill_1
XFILLER_111_203 VGND VGND VPWR VPWR sky130_fd_sc_hd__decap_3
XFILLER_88_83 VGND VGND VPWR VPWR sky130_fd_sc_hd__fill_1
XFILLER_97_437 VGND VGND VPWR VPWR sky130_fd_sc_hd__decap_3
XFILLER_88_94 VGND VGND VPWR VPWR sky130_fd_sc_hd__decap_3
XFILLER_69_128 VGND VGND VPWR VPWR sky130_fd_sc_hd__decap_3
XFILLER_33_6 VGND VGND VPWR VPWR sky130_fd_sc_hd__fill_1
XFILLER_111_225 VGND VGND VPWR VPWR sky130_fd_sc_hd__decap_3
XFILLER_78_640 VGND VGND VPWR VPWR sky130_fd_sc_hd__decap_3
XFILLER_111_247 VGND VGND VPWR VPWR sky130_fd_sc_hd__decap_3
XFILLER_78_651 VGND VGND VPWR VPWR sky130_fd_sc_hd__decap_3
XFILLER_78_684 VGND VGND VPWR VPWR sky130_fd_sc_hd__decap_3
XFILLER_77_150 VGND VGND VPWR VPWR sky130_fd_sc_hd__decap_3
XFILLER_77_172 VGND VGND VPWR VPWR sky130_fd_sc_hd__decap_3
XFILLER_93_632 VGND VGND VPWR VPWR sky130_fd_sc_hd__decap_3
XFILLER_93_665 VGND VGND VPWR VPWR sky130_fd_sc_hd__decap_3
XFILLER_93_676 VGND VGND VPWR VPWR sky130_fd_sc_hd__decap_3
XFILLER_80_304 VGND VGND VPWR VPWR sky130_fd_sc_hd__decap_3
XFILLER_80_315 VGND VGND VPWR VPWR sky130_fd_sc_hd__decap_3
XFILLER_34_710 VGND VGND VPWR VPWR sky130_fd_sc_hd__decap_3
XPHY_EDGE_ROW_87_Right_87 VGND VGND VPWR VPWR sky130_fd_sc_hd__decap_3
XTAP_TAPCELL_ROW_36_738 VGND VPWR sky130_fd_sc_hd__tapvpwrvgnd_1
XFILLER_92_186 VGND VGND VPWR VPWR sky130_fd_sc_hd__decap_3
XFILLER_46_581 VGND VGND VPWR VPWR sky130_fd_sc_hd__decap_3
XFILLER_18_294 VGND VGND VPWR VPWR sky130_fd_sc_hd__fill_1
XFILLER_33_253 VGND VGND VPWR VPWR sky130_fd_sc_hd__decap_3
X_4822_ _5040_/S _7002_/D _5663_/B _4821_/X VGND VGND VPWR VPWR _4822_/X sky130_fd_sc_hd__o22a_2
XTAP_TAPCELL_ROW_16_473 VGND VPWR sky130_fd_sc_hd__tapvpwrvgnd_1
XFILLER_61_595 VGND VGND VPWR VPWR sky130_fd_sc_hd__fill_2
X_4753_ _4753_/A0 _4752_/X _4837_/S VGND VGND VPWR VPWR _7276_/D sky130_fd_sc_hd__mux2_2
XFILLER_119_303 VGND VGND VPWR VPWR sky130_fd_sc_hd__decap_3
X_3704_ _6712_/Q _3767_/A2 _3759_/B1 _6890_/Q _3703_/X VGND VGND VPWR VPWR _3704_/X
+ sky130_fd_sc_hd__a221o_2
X_4684_ _6996_/Q _4668_/X _4943_/A _4683_/X VGND VGND VPWR VPWR _4684_/X sky130_fd_sc_hd__a31o_2
X_6423_ _6556_/A VGND VGND VPWR VPWR _6423_/Y sky130_fd_sc_hd__inv_2
X_3635_ _3635_/A _3635_/B _3547_/A VGND VGND VPWR VPWR _3635_/X sky130_fd_sc_hd__or3b_2
XPHY_EDGE_ROW_96_Right_96 VGND VGND VPWR VPWR sky130_fd_sc_hd__decap_3
XFILLER_115_520 VGND VGND VPWR VPWR sky130_fd_sc_hd__decap_3
X_6354_ _6680_/A VGND VGND VPWR VPWR _6354_/Y sky130_fd_sc_hd__inv_2
XFILLER_108_38 VGND VGND VPWR VPWR sky130_fd_sc_hd__decap_3
X_3566_ _7189_/Q _4471_/S _4354_/B1 _7381_/Q VGND VGND VPWR VPWR _3566_/X sky130_fd_sc_hd__a22o_2
XFILLER_115_553 VGND VGND VPWR VPWR sky130_fd_sc_hd__decap_3
XFILLER_88_404 VGND VGND VPWR VPWR sky130_fd_sc_hd__decap_3
XFILLER_115_564 VGND VGND VPWR VPWR sky130_fd_sc_hd__decap_3
XFILLER_103_715 VGND VGND VPWR VPWR sky130_fd_sc_hd__decap_3
X_3497_ _7151_/Q _3409_/X _3493_/X _3496_/X VGND VGND VPWR VPWR _3497_/X sky130_fd_sc_hd__a211o_2
X_6285_ _6462_/A VGND VGND VPWR VPWR _6285_/Y sky130_fd_sc_hd__inv_2
XFILLER_115_597 VGND VGND VPWR VPWR sky130_fd_sc_hd__decap_3
X_5236_ _5236_/A0 _4752_/X _5258_/S VGND VGND VPWR VPWR _7212_/D sky130_fd_sc_hd__mux2_2
XFILLER_102_247 VGND VGND VPWR VPWR sky130_fd_sc_hd__fill_1
XFILLER_69_662 VGND VGND VPWR VPWR sky130_fd_sc_hd__decap_3
XFILLER_69_673 VGND VGND VPWR VPWR sky130_fd_sc_hd__decap_3
X_5167_ _5167_/A _5200_/B VGND VGND VPWR VPWR _7244_/D sky130_fd_sc_hd__and2_2
XFILLER_84_610 VGND VGND VPWR VPWR sky130_fd_sc_hd__decap_3
XFILLER_96_492 VGND VGND VPWR VPWR sky130_fd_sc_hd__decap_3
X_4118_ _7021_/Q _4422_/A2 _4108_/B _7364_/Q VGND VGND VPWR VPWR _4118_/X sky130_fd_sc_hd__a22o_2
XFILLER_84_643 VGND VGND VPWR VPWR sky130_fd_sc_hd__fill_1
XFILLER_68_194 VGND VGND VPWR VPWR sky130_fd_sc_hd__fill_2
XFILLER_110_280 VGND VGND VPWR VPWR sky130_fd_sc_hd__fill_1
X_5098_ _5098_/A _5098_/B VGND VGND VPWR VPWR _6985_/D sky130_fd_sc_hd__nor2_2
XFILLER_84_654 VGND VGND VPWR VPWR sky130_fd_sc_hd__decap_3
XFILLER_84_687 VGND VGND VPWR VPWR sky130_fd_sc_hd__decap_3
XFILLER_83_153 VGND VGND VPWR VPWR sky130_fd_sc_hd__decap_3
X_4049_ _7213_/Q _3935_/S _4837_/S _7309_/Q _4048_/X VGND VGND VPWR VPWR _4049_/X
+ sky130_fd_sc_hd__a221o_2
XFILLER_71_326 VGND VGND VPWR VPWR sky130_fd_sc_hd__fill_2
XFILLER_25_721 VGND VGND VPWR VPWR sky130_fd_sc_hd__decap_3
XFILLER_17_57 VGND VGND VPWR VPWR sky130_fd_sc_hd__decap_3
XFILLER_25_732 VGND VGND VPWR VPWR sky130_fd_sc_hd__decap_3
XFILLER_24_242 VGND VGND VPWR VPWR sky130_fd_sc_hd__decap_3
XFILLER_24_253 VGND VGND VPWR VPWR sky130_fd_sc_hd__decap_3
XFILLER_40_713 VGND VGND VPWR VPWR sky130_fd_sc_hd__decap_3
XFILLER_12_404 VGND VGND VPWR VPWR sky130_fd_sc_hd__fill_2
XFILLER_24_286 VGND VGND VPWR VPWR sky130_fd_sc_hd__decap_3
XFILLER_12_437 VGND VGND VPWR VPWR sky130_fd_sc_hd__decap_3
XFILLER_33_45 VGND VGND VPWR VPWR sky130_fd_sc_hd__decap_3
XFILLER_8_419 VGND VGND VPWR VPWR sky130_fd_sc_hd__fill_1
XFILLER_33_67 VGND VGND VPWR VPWR sky130_fd_sc_hd__decap_3
XFILLER_33_89 VGND VGND VPWR VPWR sky130_fd_sc_hd__decap_3
XFILLER_20_481 VGND VGND VPWR VPWR sky130_fd_sc_hd__fill_1
XFILLER_4_625 VGND VGND VPWR VPWR sky130_fd_sc_hd__decap_3
XFILLER_3_102 VGND VGND VPWR VPWR sky130_fd_sc_hd__fill_2
XFILLER_106_520 VGND VGND VPWR VPWR sky130_fd_sc_hd__decap_3
XFILLER_106_542 VGND VGND VPWR VPWR sky130_fd_sc_hd__decap_3
XFILLER_4_669 VGND VGND VPWR VPWR sky130_fd_sc_hd__decap_3
XFILLER_106_575 VGND VGND VPWR VPWR sky130_fd_sc_hd__decap_3
XFILLER_79_426 VGND VGND VPWR VPWR sky130_fd_sc_hd__fill_1
XFILLER_121_523 VGND VGND VPWR VPWR sky130_fd_sc_hd__decap_3
XFILLER_121_556 VGND VGND VPWR VPWR sky130_fd_sc_hd__decap_3
XFILLER_121_567 VGND VGND VPWR VPWR sky130_fd_sc_hd__decap_3
XFILLER_59_172 VGND VGND VPWR VPWR sky130_fd_sc_hd__fill_1
XFILLER_75_632 VGND VGND VPWR VPWR sky130_fd_sc_hd__decap_3
XFILLER_47_334 VGND VGND VPWR VPWR sky130_fd_sc_hd__fill_2
XFILLER_75_665 VGND VGND VPWR VPWR sky130_fd_sc_hd__decap_3
XFILLER_75_676 VGND VGND VPWR VPWR sky130_fd_sc_hd__decap_3
XFILLER_74_153 VGND VGND VPWR VPWR sky130_fd_sc_hd__decap_3
XFILLER_90_613 VGND VGND VPWR VPWR sky130_fd_sc_hd__decap_3
XFILLER_62_304 VGND VGND VPWR VPWR sky130_fd_sc_hd__decap_3
XFILLER_62_315 VGND VGND VPWR VPWR sky130_fd_sc_hd__decap_3
XFILLER_47_389 VGND VGND VPWR VPWR sky130_fd_sc_hd__decap_3
XFILLER_16_710 VGND VGND VPWR VPWR sky130_fd_sc_hd__decap_3
XFILLER_74_197 VGND VGND VPWR VPWR sky130_fd_sc_hd__decap_3
XFILLER_28_592 VGND VGND VPWR VPWR sky130_fd_sc_hd__decap_3
XFILLER_90_657 VGND VGND VPWR VPWR sky130_fd_sc_hd__decap_3
XFILLER_74_96 VGND VGND VPWR VPWR sky130_fd_sc_hd__decap_3
XFILLER_15_231 VGND VGND VPWR VPWR sky130_fd_sc_hd__fill_1
XFILLER_31_724 VGND VGND VPWR VPWR sky130_fd_sc_hd__decap_3
XFILLER_15_286 VGND VGND VPWR VPWR sky130_fd_sc_hd__decap_3
XTAP_TAPCELL_ROW_13_432 VGND VPWR sky130_fd_sc_hd__tapvpwrvgnd_1
XTAP_TAPCELL_ROW_41_796 VGND VPWR sky130_fd_sc_hd__tapvpwrvgnd_1
XFILLER_7_430 VGND VGND VPWR VPWR sky130_fd_sc_hd__decap_3
XTAP_TAPCELL_ROW_96_1515 VGND VPWR sky130_fd_sc_hd__tapvpwrvgnd_1
XFILLER_7_452 VGND VGND VPWR VPWR sky130_fd_sc_hd__fill_2
XFILLER_116_306 VGND VGND VPWR VPWR sky130_fd_sc_hd__fill_2
XFILLER_99_60 VGND VGND VPWR VPWR sky130_fd_sc_hd__decap_3
X_3420_ _3420_/A _5642_/B VGND VGND VPWR VPWR _3442_/B sky130_fd_sc_hd__or2_2
XFILLER_109_380 VGND VGND VPWR VPWR sky130_fd_sc_hd__decap_3
X_3351_ _5130_/A _3350_/Y _3340_/B VGND VGND VPWR VPWR _5642_/B sky130_fd_sc_hd__o21a_2
XFILLER_98_713 VGND VGND VPWR VPWR sky130_fd_sc_hd__decap_3
XFILLER_3_691 VGND VGND VPWR VPWR sky130_fd_sc_hd__decap_3
XFILLER_112_545 VGND VGND VPWR VPWR sky130_fd_sc_hd__decap_3
XFILLER_97_256 VGND VGND VPWR VPWR sky130_fd_sc_hd__fill_1
XFILLER_100_707 VGND VGND VPWR VPWR sky130_fd_sc_hd__decap_3
XFILLER_112_578 VGND VGND VPWR VPWR sky130_fd_sc_hd__decap_3
X_5021_ _5072_/A _4372_/A _5018_/A _5101_/A VGND VGND VPWR VPWR _5021_/X sky130_fd_sc_hd__o2bb2a_2
Xhold1108 _7163_/Q VGND VGND VPWR VPWR _5336_/A0 sky130_fd_sc_hd__dlygate4sd3_1
XFILLER_57_109 VGND VGND VPWR VPWR sky130_fd_sc_hd__decap_3
Xhold1119 _7292_/Q VGND VGND VPWR VPWR _4577_/A sky130_fd_sc_hd__dlygate4sd3_1
XFILLER_112_589 VGND VGND VPWR VPWR sky130_fd_sc_hd__decap_3
XFILLER_38_301 VGND VGND VPWR VPWR sky130_fd_sc_hd__decap_3
XFILLER_66_621 VGND VGND VPWR VPWR sky130_fd_sc_hd__decap_3
XFILLER_38_312 VGND VGND VPWR VPWR sky130_fd_sc_hd__fill_1
XFILLER_78_492 VGND VGND VPWR VPWR sky130_fd_sc_hd__decap_3
XFILLER_66_654 VGND VGND VPWR VPWR sky130_fd_sc_hd__decap_3
XFILLER_93_473 VGND VGND VPWR VPWR sky130_fd_sc_hd__decap_3
XFILLER_66_687 VGND VGND VPWR VPWR sky130_fd_sc_hd__decap_3
XFILLER_26_529 VGND VGND VPWR VPWR sky130_fd_sc_hd__decap_3
X_6972_ _7380_/CLK _6972_/D VGND VGND VPWR VPWR _6972_/Q sky130_fd_sc_hd__dfxtp_2
XFILLER_19_570 VGND VGND VPWR VPWR sky130_fd_sc_hd__decap_3
XFILLER_93_495 VGND VGND VPWR VPWR sky130_fd_sc_hd__decap_3
XFILLER_81_635 VGND VGND VPWR VPWR sky130_fd_sc_hd__decap_3
XFILLER_53_348 VGND VGND VPWR VPWR sky130_fd_sc_hd__decap_3
XTAP_TAPCELL_ROW_105_1633 VGND VPWR sky130_fd_sc_hd__tapvpwrvgnd_1
XFILLER_81_668 VGND VGND VPWR VPWR sky130_fd_sc_hd__decap_3
XFILLER_81_679 VGND VGND VPWR VPWR sky130_fd_sc_hd__decap_3
XFILLER_22_713 VGND VGND VPWR VPWR sky130_fd_sc_hd__decap_3
XFILLER_80_189 VGND VGND VPWR VPWR sky130_fd_sc_hd__decap_3
XFILLER_34_595 VGND VGND VPWR VPWR sky130_fd_sc_hd__decap_3
X_4805_ _4997_/A1 _7003_/D _4804_/X VGND VGND VPWR VPWR _4805_/X sky130_fd_sc_hd__a21bo_2
XFILLER_21_234 VGND VGND VPWR VPWR sky130_fd_sc_hd__decap_3
XFILLER_21_267 VGND VGND VPWR VPWR sky130_fd_sc_hd__decap_3
XFILLER_119_111 VGND VGND VPWR VPWR sky130_fd_sc_hd__fill_1
XFILLER_119_15 VGND VGND VPWR VPWR sky130_fd_sc_hd__decap_3
XFILLER_119_48 VGND VGND VPWR VPWR sky130_fd_sc_hd__decap_3
X_4667_ _6998_/Q _4667_/B VGND VGND VPWR VPWR _4896_/A sky130_fd_sc_hd__xnor2_2
X_6406_ _6632_/A VGND VGND VPWR VPWR _6406_/Y sky130_fd_sc_hd__inv_2
X_3618_ _5118_/C _4938_/A _4764_/B VGND VGND VPWR VPWR _3618_/X sky130_fd_sc_hd__and3_2
Xhold920 _6701_/Q VGND VGND VPWR VPWR hold920/X sky130_fd_sc_hd__dlygate4sd3_1
Xhold931 _7036_/Q VGND VGND VPWR VPWR hold931/X sky130_fd_sc_hd__dlygate4sd3_1
X_7386_ _7386_/CLK _7386_/D _6666_/Y VGND VGND VPWR VPWR _7386_/Q sky130_fd_sc_hd__dfrtp_2
XTAP_TAPCELL_ROW_116_1773 VGND VPWR sky130_fd_sc_hd__tapvpwrvgnd_1
Xhold942 _7023_/Q VGND VGND VPWR VPWR _5609_/A sky130_fd_sc_hd__dlygate4sd3_1
XFILLER_122_309 VGND VGND VPWR VPWR sky130_fd_sc_hd__fill_1
Xhold953 _7045_/Q VGND VGND VPWR VPWR hold953/X sky130_fd_sc_hd__dlygate4sd3_1
XFILLER_1_606 VGND VGND VPWR VPWR sky130_fd_sc_hd__decap_3
X_6337_ _6630_/A VGND VGND VPWR VPWR _6337_/Y sky130_fd_sc_hd__inv_2
Xhold964 _7047_/Q VGND VGND VPWR VPWR hold964/X sky130_fd_sc_hd__dlygate4sd3_1
XFILLER_89_724 VGND VGND VPWR VPWR sky130_fd_sc_hd__decap_3
XFILLER_1_617 VGND VGND VPWR VPWR sky130_fd_sc_hd__decap_3
Xhold975 _7051_/Q VGND VGND VPWR VPWR hold975/X sky130_fd_sc_hd__dlygate4sd3_1
Xhold986 _7190_/Q VGND VGND VPWR VPWR hold986/X sky130_fd_sc_hd__dlygate4sd3_1
XFILLER_88_223 VGND VGND VPWR VPWR sky130_fd_sc_hd__decap_3
Xhold997 _7192_/Q VGND VGND VPWR VPWR hold997/X sky130_fd_sc_hd__dlygate4sd3_1
X_6268_ _6363_/A VGND VGND VPWR VPWR _6268_/Y sky130_fd_sc_hd__inv_2
XFILLER_103_556 VGND VGND VPWR VPWR sky130_fd_sc_hd__decap_3
XFILLER_103_567 VGND VGND VPWR VPWR sky130_fd_sc_hd__decap_3
XFILLER_95_29 VGND VGND VPWR VPWR sky130_fd_sc_hd__fill_1
XFILLER_76_407 VGND VGND VPWR VPWR sky130_fd_sc_hd__decap_3
X_5219_ _5219_/A _5223_/B VGND VGND VPWR VPWR _7219_/D sky130_fd_sc_hd__and2_2
XFILLER_69_470 VGND VGND VPWR VPWR sky130_fd_sc_hd__decap_3
XFILLER_57_632 VGND VGND VPWR VPWR sky130_fd_sc_hd__decap_3
XFILLER_57_665 VGND VGND VPWR VPWR sky130_fd_sc_hd__decap_3
XFILLER_57_676 VGND VGND VPWR VPWR sky130_fd_sc_hd__decap_3
XFILLER_72_613 VGND VGND VPWR VPWR sky130_fd_sc_hd__decap_3
XFILLER_71_101 VGND VGND VPWR VPWR sky130_fd_sc_hd__decap_3
XFILLER_44_315 VGND VGND VPWR VPWR sky130_fd_sc_hd__decap_3
XTAP_TAPCELL_ROW_67_1138 VGND VPWR sky130_fd_sc_hd__tapvpwrvgnd_1
XFILLER_56_197 VGND VGND VPWR VPWR sky130_fd_sc_hd__decap_3
XFILLER_44_337 VGND VGND VPWR VPWR sky130_fd_sc_hd__decap_3
XFILLER_72_657 VGND VGND VPWR VPWR sky130_fd_sc_hd__decap_3
XFILLER_71_145 VGND VGND VPWR VPWR sky130_fd_sc_hd__decap_3
XFILLER_44_22 VGND VGND VPWR VPWR sky130_fd_sc_hd__fill_1
XTAP_TAPCELL_ROW_80_1305 VGND VPWR sky130_fd_sc_hd__tapvpwrvgnd_1
XFILLER_25_573 VGND VGND VPWR VPWR sky130_fd_sc_hd__decap_3
XFILLER_71_189 VGND VGND VPWR VPWR sky130_fd_sc_hd__decap_3
XFILLER_40_510 VGND VGND VPWR VPWR sky130_fd_sc_hd__decap_3
XFILLER_13_724 VGND VGND VPWR VPWR sky130_fd_sc_hd__decap_3
XFILLER_80_690 VGND VGND VPWR VPWR sky130_fd_sc_hd__decap_3
XFILLER_52_392 VGND VGND VPWR VPWR sky130_fd_sc_hd__fill_2
XFILLER_9_706 VGND VGND VPWR VPWR sky130_fd_sc_hd__decap_3
XFILLER_12_234 VGND VGND VPWR VPWR sky130_fd_sc_hd__decap_3
XFILLER_40_565 VGND VGND VPWR VPWR sky130_fd_sc_hd__decap_3
XFILLER_12_256 VGND VGND VPWR VPWR sky130_fd_sc_hd__decap_3
XFILLER_8_216 VGND VGND VPWR VPWR sky130_fd_sc_hd__decap_3
XFILLER_40_587 VGND VGND VPWR VPWR sky130_fd_sc_hd__fill_1
XTAP_TAPCELL_ROW_10_402 VGND VPWR sky130_fd_sc_hd__tapvpwrvgnd_1
XFILLER_60_32 VGND VGND VPWR VPWR sky130_fd_sc_hd__decap_3
XFILLER_40_598 VGND VGND VPWR VPWR sky130_fd_sc_hd__decap_3
XFILLER_100_94 VGND VGND VPWR VPWR sky130_fd_sc_hd__fill_2
XTAP_TAPCELL_ROW_78_1278 VGND VPWR sky130_fd_sc_hd__tapvpwrvgnd_1
XFILLER_5_49 VGND VGND VPWR VPWR sky130_fd_sc_hd__decap_3
XFILLER_69_30 VGND VGND VPWR VPWR sky130_fd_sc_hd__decap_3
XFILLER_4_477 VGND VGND VPWR VPWR sky130_fd_sc_hd__decap_3
XFILLER_79_201 VGND VGND VPWR VPWR sky130_fd_sc_hd__decap_3
XTAP_TAPCELL_ROW_91_1445 VGND VPWR sky130_fd_sc_hd__tapvpwrvgnd_1
XTAP_TAPCELL_ROW_91_1456 VGND VPWR sky130_fd_sc_hd__tapvpwrvgnd_1
XFILLER_121_320 VGND VGND VPWR VPWR sky130_fd_sc_hd__decap_3
XFILLER_79_256 VGND VGND VPWR VPWR sky130_fd_sc_hd__decap_3
XFILLER_95_727 VGND VGND VPWR VPWR sky130_fd_sc_hd__fill_1
XFILLER_94_215 VGND VGND VPWR VPWR sky130_fd_sc_hd__decap_3
XFILLER_48_621 VGND VGND VPWR VPWR sky130_fd_sc_hd__decap_3
XFILLER_121_397 VGND VGND VPWR VPWR sky130_fd_sc_hd__fill_1
XFILLER_94_259 VGND VGND VPWR VPWR sky130_fd_sc_hd__decap_3
XFILLER_48_654 VGND VGND VPWR VPWR sky130_fd_sc_hd__decap_3
XFILLER_85_73 VGND VGND VPWR VPWR sky130_fd_sc_hd__decap_3
XFILLER_63_613 VGND VGND VPWR VPWR sky130_fd_sc_hd__decap_3
XFILLER_48_687 VGND VGND VPWR VPWR sky130_fd_sc_hd__decap_3
XTAP_TAPCELL_ROW_18_502 VGND VPWR sky130_fd_sc_hd__tapvpwrvgnd_1
XFILLER_47_175 VGND VGND VPWR VPWR sky130_fd_sc_hd__decap_3
XFILLER_63_635 VGND VGND VPWR VPWR sky130_fd_sc_hd__decap_3
XFILLER_35_337 VGND VGND VPWR VPWR sky130_fd_sc_hd__decap_3
XFILLER_63_668 VGND VGND VPWR VPWR sky130_fd_sc_hd__decap_3
XTAP_TAPCELL_ROW_46_866 VGND VPWR sky130_fd_sc_hd__tapvpwrvgnd_1
XFILLER_63_679 VGND VGND VPWR VPWR sky130_fd_sc_hd__decap_3
XFILLER_50_318 VGND VGND VPWR VPWR sky130_fd_sc_hd__decap_3
XFILLER_16_573 VGND VGND VPWR VPWR sky130_fd_sc_hd__decap_3
XFILLER_31_521 VGND VGND VPWR VPWR sky130_fd_sc_hd__fill_1
XFILLER_16_595 VGND VGND VPWR VPWR sky130_fd_sc_hd__decap_3
XTAP_TAPCELL_ROW_100_1563 VGND VPWR sky130_fd_sc_hd__tapvpwrvgnd_1
X_5570_ hold964/X _4983_/A _4929_/Y VGND VGND VPWR VPWR _7047_/D sky130_fd_sc_hd__o21a_2
XFILLER_79_3 VGND VGND VPWR VPWR sky130_fd_sc_hd__decap_3
XFILLER_117_615 VGND VGND VPWR VPWR sky130_fd_sc_hd__fill_1
XFILLER_117_626 VGND VGND VPWR VPWR sky130_fd_sc_hd__decap_3
XFILLER_116_103 VGND VGND VPWR VPWR sky130_fd_sc_hd__decap_3
X_7240_ _7374_/CLK _7240_/D _6520_/Y VGND VGND VPWR VPWR _7240_/Q sky130_fd_sc_hd__dfrtp_2
XFILLER_117_659 VGND VGND VPWR VPWR sky130_fd_sc_hd__decap_3
X_4452_ _4452_/A _4765_/B VGND VGND VPWR VPWR _4453_/A sky130_fd_sc_hd__or2_2
XFILLER_7_293 VGND VGND VPWR VPWR sky130_fd_sc_hd__decap_3
XFILLER_104_309 VGND VGND VPWR VPWR sky130_fd_sc_hd__fill_1
X_3403_ _5667_/A _4467_/B VGND VGND VPWR VPWR _4667_/B sky130_fd_sc_hd__or2_4
X_7171_ _7395_/CLK _7171_/D _6451_/Y VGND VGND VPWR VPWR _7171_/Q sky130_fd_sc_hd__dfrtp_2
X_4383_ _4920_/A _4937_/A _4383_/C VGND VGND VPWR VPWR _4384_/C sky130_fd_sc_hd__and3_2
X_3334_ _3330_/Y _3528_/A _5156_/S VGND VGND VPWR VPWR _3334_/Y sky130_fd_sc_hd__o21ai_2
XFILLER_112_331 VGND VGND VPWR VPWR sky130_fd_sc_hd__fill_2
XFILLER_98_565 VGND VGND VPWR VPWR sky130_fd_sc_hd__decap_3
XFILLER_86_716 VGND VGND VPWR VPWR sky130_fd_sc_hd__decap_3
XFILLER_58_407 VGND VGND VPWR VPWR sky130_fd_sc_hd__decap_3
XFILLER_100_504 VGND VGND VPWR VPWR sky130_fd_sc_hd__decap_3
XFILLER_58_418 VGND VGND VPWR VPWR sky130_fd_sc_hd__fill_2
XPHY_EDGE_ROW_0_Left_124 VGND VGND VPWR VPWR sky130_fd_sc_hd__decap_3
XFILLER_98_598 VGND VGND VPWR VPWR sky130_fd_sc_hd__decap_3
XFILLER_112_375 VGND VGND VPWR VPWR sky130_fd_sc_hd__decap_3
XFILLER_105_39 VGND VGND VPWR VPWR sky130_fd_sc_hd__fill_2
XFILLER_39_632 VGND VGND VPWR VPWR sky130_fd_sc_hd__decap_3
X_5004_ _5004_/A _5004_/B VGND VGND VPWR VPWR _5004_/X sky130_fd_sc_hd__or2_2
XFILLER_85_259 VGND VGND VPWR VPWR sky130_fd_sc_hd__decap_3
XFILLER_100_559 VGND VGND VPWR VPWR sky130_fd_sc_hd__decap_3
XFILLER_39_665 VGND VGND VPWR VPWR sky130_fd_sc_hd__decap_3
XFILLER_39_676 VGND VGND VPWR VPWR sky130_fd_sc_hd__decap_3
XFILLER_54_613 VGND VGND VPWR VPWR sky130_fd_sc_hd__decap_3
XFILLER_26_315 VGND VGND VPWR VPWR sky130_fd_sc_hd__decap_3
XFILLER_38_175 VGND VGND VPWR VPWR sky130_fd_sc_hd__decap_3
XFILLER_93_281 VGND VGND VPWR VPWR sky130_fd_sc_hd__decap_3
XFILLER_38_186 VGND VGND VPWR VPWR sky130_fd_sc_hd__decap_3
XFILLER_38_197 VGND VGND VPWR VPWR sky130_fd_sc_hd__decap_3
XFILLER_54_657 VGND VGND VPWR VPWR sky130_fd_sc_hd__decap_3
XFILLER_26_348 VGND VGND VPWR VPWR sky130_fd_sc_hd__decap_3
XFILLER_121_27 VGND VGND VPWR VPWR sky130_fd_sc_hd__decap_3
X_6955_ _6967_/CLK _6955_/D VGND VGND VPWR VPWR _6955_/Q sky130_fd_sc_hd__dfxtp_2
XFILLER_41_318 VGND VGND VPWR VPWR sky130_fd_sc_hd__decap_3
X_6886_ _6942_/CLK _6886_/D VGND VGND VPWR VPWR _6886_/Q sky130_fd_sc_hd__dfxtp_2
XFILLER_62_690 VGND VGND VPWR VPWR sky130_fd_sc_hd__decap_3
XTAP_TAPCELL_ROW_62_1068 VGND VPWR sky130_fd_sc_hd__tapvpwrvgnd_1
XFILLER_10_716 VGND VGND VPWR VPWR sky130_fd_sc_hd__decap_3
XTAP_TAPCELL_ROW_62_1079 VGND VPWR sky130_fd_sc_hd__tapvpwrvgnd_1
XFILLER_22_587 VGND VGND VPWR VPWR sky130_fd_sc_hd__fill_1
XFILLER_22_598 VGND VGND VPWR VPWR sky130_fd_sc_hd__decap_3
XTAP_TAPCELL_ROW_118_1802 VGND VPWR sky130_fd_sc_hd__tapvpwrvgnd_1
XFILLER_108_604 VGND VGND VPWR VPWR sky130_fd_sc_hd__decap_3
X_5699_ _7355_/Q _5699_/A1 _5708_/S VGND VGND VPWR VPWR _6699_/D sky130_fd_sc_hd__mux2_2
XFILLER_30_24 VGND VGND VPWR VPWR sky130_fd_sc_hd__decap_3
XFILLER_108_637 VGND VGND VPWR VPWR sky130_fd_sc_hd__decap_3
XFILLER_108_648 VGND VGND VPWR VPWR sky130_fd_sc_hd__decap_3
XFILLER_30_46 VGND VGND VPWR VPWR sky130_fd_sc_hd__fill_1
XFILLER_107_125 VGND VGND VPWR VPWR sky130_fd_sc_hd__decap_3
XFILLER_107_158 VGND VGND VPWR VPWR sky130_fd_sc_hd__decap_3
XFILLER_107_169 VGND VGND VPWR VPWR sky130_fd_sc_hd__decap_3
XFILLER_100_6 VGND VGND VPWR VPWR sky130_fd_sc_hd__decap_3
XFILLER_123_629 VGND VGND VPWR VPWR sky130_fd_sc_hd__decap_3
Xhold750 _6777_/Q VGND VGND VPWR VPWR _6777_/D sky130_fd_sc_hd__dlygate4sd3_1
XFILLER_122_106 VGND VGND VPWR VPWR sky130_fd_sc_hd__decap_3
X_7369_ _7405_/CLK _7369_/D _6649_/Y VGND VGND VPWR VPWR _7369_/Q sky130_fd_sc_hd__dfrtp_2
Xhold761 _6925_/Q VGND VGND VPWR VPWR _6925_/D sky130_fd_sc_hd__dlygate4sd3_1
XFILLER_116_681 VGND VGND VPWR VPWR sky130_fd_sc_hd__decap_3
Xhold772 _6917_/Q VGND VGND VPWR VPWR _6917_/D sky130_fd_sc_hd__dlygate4sd3_1
Xhold783 _6832_/Q VGND VGND VPWR VPWR _6832_/D sky130_fd_sc_hd__dlygate4sd3_1
XFILLER_115_180 VGND VGND VPWR VPWR sky130_fd_sc_hd__decap_3
Xhold794 _6743_/Q VGND VGND VPWR VPWR _6743_/D sky130_fd_sc_hd__dlygate4sd3_1
XFILLER_1_447 VGND VGND VPWR VPWR sky130_fd_sc_hd__fill_1
XPHY_EDGE_ROW_55_Left_179 VGND VGND VPWR VPWR sky130_fd_sc_hd__decap_3
XFILLER_89_576 VGND VGND VPWR VPWR sky130_fd_sc_hd__decap_3
XFILLER_77_727 VGND VGND VPWR VPWR sky130_fd_sc_hd__fill_1
XFILLER_39_66 VGND VGND VPWR VPWR sky130_fd_sc_hd__decap_3
XFILLER_76_237 VGND VGND VPWR VPWR sky130_fd_sc_hd__decap_3
XFILLER_76_259 VGND VGND VPWR VPWR sky130_fd_sc_hd__decap_3
XFILLER_92_719 VGND VGND VPWR VPWR sky130_fd_sc_hd__decap_3
XFILLER_57_462 VGND VGND VPWR VPWR sky130_fd_sc_hd__decap_3
XFILLER_45_613 VGND VGND VPWR VPWR sky130_fd_sc_hd__decap_3
XFILLER_17_304 VGND VGND VPWR VPWR sky130_fd_sc_hd__decap_3
XFILLER_72_421 VGND VGND VPWR VPWR sky130_fd_sc_hd__decap_3
XFILLER_45_635 VGND VGND VPWR VPWR sky130_fd_sc_hd__decap_3
XFILLER_84_281 VGND VGND VPWR VPWR sky130_fd_sc_hd__decap_3
XFILLER_44_123 VGND VGND VPWR VPWR sky130_fd_sc_hd__fill_2
XFILLER_55_76 VGND VGND VPWR VPWR sky130_fd_sc_hd__decap_3
XFILLER_45_668 VGND VGND VPWR VPWR sky130_fd_sc_hd__decap_3
XFILLER_45_679 VGND VGND VPWR VPWR sky130_fd_sc_hd__decap_3
XFILLER_60_616 VGND VGND VPWR VPWR sky130_fd_sc_hd__decap_3
XFILLER_32_318 VGND VGND VPWR VPWR sky130_fd_sc_hd__decap_3
XTAP_TAPCELL_ROW_43_825 VGND VPWR sky130_fd_sc_hd__tapvpwrvgnd_1
XPHY_EDGE_ROW_105_Right_105 VGND VGND VPWR VPWR sky130_fd_sc_hd__decap_3
XFILLER_111_60 VGND VGND VPWR VPWR sky130_fd_sc_hd__decap_3
XPHY_EDGE_ROW_64_Left_188 VGND VGND VPWR VPWR sky130_fd_sc_hd__decap_3
XFILLER_9_503 VGND VGND VPWR VPWR sky130_fd_sc_hd__fill_1
XFILLER_13_554 VGND VGND VPWR VPWR sky130_fd_sc_hd__decap_3
XFILLER_40_351 VGND VGND VPWR VPWR sky130_fd_sc_hd__decap_3
XFILLER_13_576 VGND VGND VPWR VPWR sky130_fd_sc_hd__decap_3
XTAP_TAPCELL_ROW_23_560 VGND VPWR sky130_fd_sc_hd__tapvpwrvgnd_1
XFILLER_9_547 VGND VGND VPWR VPWR sky130_fd_sc_hd__decap_3
XTAP_TAPCELL_ROW_23_571 VGND VPWR sky130_fd_sc_hd__tapvpwrvgnd_1
XFILLER_65_9 VGND VGND VPWR VPWR sky130_fd_sc_hd__decap_3
XFILLER_4_230 VGND VGND VPWR VPWR sky130_fd_sc_hd__decap_3
XFILLER_114_607 VGND VGND VPWR VPWR sky130_fd_sc_hd__decap_3
XPHY_EDGE_ROW_73_Left_197 VGND VGND VPWR VPWR sky130_fd_sc_hd__decap_3
XFILLER_122_640 VGND VGND VPWR VPWR sky130_fd_sc_hd__decap_3
XFILLER_122_651 VGND VGND VPWR VPWR sky130_fd_sc_hd__decap_3
XFILLER_68_716 VGND VGND VPWR VPWR sky130_fd_sc_hd__decap_3
XFILLER_67_204 VGND VGND VPWR VPWR sky130_fd_sc_hd__decap_3
XFILLER_122_684 VGND VGND VPWR VPWR sky130_fd_sc_hd__decap_3
XFILLER_95_524 VGND VGND VPWR VPWR sky130_fd_sc_hd__decap_3
XFILLER_96_83 VGND VGND VPWR VPWR sky130_fd_sc_hd__fill_1
XFILLER_95_546 VGND VGND VPWR VPWR sky130_fd_sc_hd__fill_2
XFILLER_121_183 VGND VGND VPWR VPWR sky130_fd_sc_hd__fill_1
XFILLER_0_491 VGND VGND VPWR VPWR sky130_fd_sc_hd__decap_3
XFILLER_48_440 VGND VGND VPWR VPWR sky130_fd_sc_hd__decap_3
XFILLER_95_579 VGND VGND VPWR VPWR sky130_fd_sc_hd__decap_3
XFILLER_36_613 VGND VGND VPWR VPWR sky130_fd_sc_hd__decap_3
XFILLER_82_229 VGND VGND VPWR VPWR sky130_fd_sc_hd__fill_1
XFILLER_75_281 VGND VGND VPWR VPWR sky130_fd_sc_hd__decap_3
Xplace410 _3380_/Y VGND VGND VPWR VPWR _4354_/B1 sky130_fd_sc_hd__buf_2
XFILLER_36_657 VGND VGND VPWR VPWR sky130_fd_sc_hd__decap_3
Xplace421 _3975_/S VGND VGND VPWR VPWR _3964_/S sky130_fd_sc_hd__buf_2
XFILLER_35_156 VGND VGND VPWR VPWR sky130_fd_sc_hd__decap_3
Xplace432 _3368_/Y VGND VGND VPWR VPWR _3394_/A sky130_fd_sc_hd__buf_2
XFILLER_90_251 VGND VGND VPWR VPWR sky130_fd_sc_hd__fill_1
Xplace443 _5587_/B VGND VGND VPWR VPWR _4909_/A sky130_fd_sc_hd__buf_2
XFILLER_90_262 VGND VGND VPWR VPWR sky130_fd_sc_hd__decap_3
XFILLER_63_476 VGND VGND VPWR VPWR sky130_fd_sc_hd__decap_3
Xplace454 _6982_/Q VGND VGND VPWR VPWR _3386_/A sky130_fd_sc_hd__buf_2
XFILLER_35_178 VGND VGND VPWR VPWR sky130_fd_sc_hd__decap_3
X_6740_ _6960_/CLK _6740_/D VGND VGND VPWR VPWR _6740_/Q sky130_fd_sc_hd__dfxtp_2
XFILLER_51_638 VGND VGND VPWR VPWR sky130_fd_sc_hd__decap_3
XFILLER_35_189 VGND VGND VPWR VPWR sky130_fd_sc_hd__decap_3
X_3952_ _7364_/Q _4495_/A0 _3964_/S VGND VGND VPWR VPWR _7364_/D sky130_fd_sc_hd__mux2_2
XFILLER_90_284 VGND VGND VPWR VPWR sky130_fd_sc_hd__decap_3
XFILLER_44_690 VGND VGND VPWR VPWR sky130_fd_sc_hd__decap_3
X_6671_ _6672_/A VGND VGND VPWR VPWR _6671_/Y sky130_fd_sc_hd__inv_2
XFILLER_31_340 VGND VGND VPWR VPWR sky130_fd_sc_hd__decap_3
X_3883_ _6814_/Q _3913_/A2 _3883_/B1 _6819_/Q VGND VGND VPWR VPWR _3883_/X sky130_fd_sc_hd__a22o_2
X_5622_ _5622_/A _5633_/B VGND VGND VPWR VPWR _7017_/D sky130_fd_sc_hd__nor2_2
X_7223_ _7355_/CLK _7223_/D _6503_/Y VGND VGND VPWR VPWR _7223_/Q sky130_fd_sc_hd__dfrtp_2
XFILLER_105_629 VGND VGND VPWR VPWR sky130_fd_sc_hd__decap_3
X_4435_ _7207_/Q _3945_/S _4394_/B _7367_/Q VGND VGND VPWR VPWR _4435_/X sky130_fd_sc_hd__a22o_2
XTAP_TAPCELL_ROW_113_1732 VGND VPWR sky130_fd_sc_hd__tapvpwrvgnd_1
XFILLER_104_128 VGND VGND VPWR VPWR sky130_fd_sc_hd__decap_3
X_7154_ _7355_/CLK _7154_/D _6434_/Y VGND VGND VPWR VPWR _7154_/Q sky130_fd_sc_hd__dfrtp_2
XFILLER_116_38 VGND VGND VPWR VPWR sky130_fd_sc_hd__decap_3
X_4366_ _4460_/A _4364_/Y _4313_/D _4361_/A _4365_/X VGND VGND VPWR VPWR _4366_/X
+ sky130_fd_sc_hd__a32o_2
XFILLER_98_351 VGND VGND VPWR VPWR sky130_fd_sc_hd__decap_3
XFILLER_113_662 VGND VGND VPWR VPWR sky130_fd_sc_hd__decap_3
XFILLER_86_513 VGND VGND VPWR VPWR sky130_fd_sc_hd__decap_3
XFILLER_59_727 VGND VGND VPWR VPWR sky130_fd_sc_hd__fill_1
XFILLER_58_204 VGND VGND VPWR VPWR sky130_fd_sc_hd__decap_3
XFILLER_113_673 VGND VGND VPWR VPWR sky130_fd_sc_hd__decap_3
XFILLER_112_150 VGND VGND VPWR VPWR sky130_fd_sc_hd__decap_3
XFILLER_98_384 VGND VGND VPWR VPWR sky130_fd_sc_hd__fill_1
X_7085_ _7371_/CLK _7085_/D _6365_/Y VGND VGND VPWR VPWR _7085_/Q sky130_fd_sc_hd__dfrtp_2
X_4297_ _5113_/A _4297_/B VGND VGND VPWR VPWR _4297_/Y sky130_fd_sc_hd__nor2_2
XFILLER_100_334 VGND VGND VPWR VPWR sky130_fd_sc_hd__decap_3
XFILLER_86_568 VGND VGND VPWR VPWR sky130_fd_sc_hd__decap_3
XFILLER_74_719 VGND VGND VPWR VPWR sky130_fd_sc_hd__decap_3
XFILLER_100_356 VGND VGND VPWR VPWR sky130_fd_sc_hd__decap_3
XFILLER_27_602 VGND VGND VPWR VPWR sky130_fd_sc_hd__decap_3
XFILLER_73_218 VGND VGND VPWR VPWR sky130_fd_sc_hd__decap_3
XFILLER_39_473 VGND VGND VPWR VPWR sky130_fd_sc_hd__fill_2
XFILLER_27_635 VGND VGND VPWR VPWR sky130_fd_sc_hd__decap_3
XFILLER_66_292 VGND VGND VPWR VPWR sky130_fd_sc_hd__fill_2
XFILLER_54_443 VGND VGND VPWR VPWR sky130_fd_sc_hd__decap_3
XFILLER_27_668 VGND VGND VPWR VPWR sky130_fd_sc_hd__decap_3
XFILLER_81_240 VGND VGND VPWR VPWR sky130_fd_sc_hd__decap_3
XFILLER_27_679 VGND VGND VPWR VPWR sky130_fd_sc_hd__decap_3
XTAP_TAPCELL_ROW_1_277 VGND VPWR sky130_fd_sc_hd__tapvpwrvgnd_1
XFILLER_42_616 VGND VGND VPWR VPWR sky130_fd_sc_hd__decap_3
X_6938_ _7403_/CLK _6938_/D VGND VGND VPWR VPWR _6938_/Q sky130_fd_sc_hd__dfxtp_2
XFILLER_81_284 VGND VGND VPWR VPWR sky130_fd_sc_hd__decap_3
XFILLER_81_295 VGND VGND VPWR VPWR sky130_fd_sc_hd__decap_3
X_6869_ _7215_/CLK _6869_/D VGND VGND VPWR VPWR _6869_/Q sky130_fd_sc_hd__dfxtp_2
XFILLER_50_660 VGND VGND VPWR VPWR sky130_fd_sc_hd__decap_3
XFILLER_50_693 VGND VGND VPWR VPWR sky130_fd_sc_hd__decap_3
XFILLER_22_384 VGND VGND VPWR VPWR sky130_fd_sc_hd__fill_2
XFILLER_41_34 VGND VGND VPWR VPWR sky130_fd_sc_hd__decap_3
XFILLER_10_557 VGND VGND VPWR VPWR sky130_fd_sc_hd__decap_3
XTAP_TAPCELL_ROW_20_530 VGND VPWR sky130_fd_sc_hd__tapvpwrvgnd_1
XFILLER_6_539 VGND VGND VPWR VPWR sky130_fd_sc_hd__decap_3
XFILLER_41_89 VGND VGND VPWR VPWR sky130_fd_sc_hd__fill_2
XTAP_TAPCELL_ROW_75_1237 VGND VPWR sky130_fd_sc_hd__tapvpwrvgnd_1
XFILLER_2_701 VGND VGND VPWR VPWR sky130_fd_sc_hd__decap_3
XTAP_TAPCELL_ROW_75_1248 VGND VPWR sky130_fd_sc_hd__tapvpwrvgnd_1
XFILLER_108_489 VGND VGND VPWR VPWR sky130_fd_sc_hd__decap_3
XFILLER_1_200 VGND VGND VPWR VPWR sky130_fd_sc_hd__decap_3
XFILLER_123_437 VGND VGND VPWR VPWR sky130_fd_sc_hd__decap_3
XFILLER_2_734 VGND VGND VPWR VPWR sky130_fd_sc_hd__fill_1
XFILLER_104_640 VGND VGND VPWR VPWR sky130_fd_sc_hd__decap_3
XFILLER_89_340 VGND VGND VPWR VPWR sky130_fd_sc_hd__fill_1
XFILLER_104_651 VGND VGND VPWR VPWR sky130_fd_sc_hd__decap_3
Xhold591 _6808_/Q VGND VGND VPWR VPWR _6808_/D sky130_fd_sc_hd__dlygate4sd3_1
XFILLER_89_351 VGND VGND VPWR VPWR sky130_fd_sc_hd__decap_3
XTAP_TAPCELL_ROW_9_388 VGND VPWR sky130_fd_sc_hd__tapvpwrvgnd_1
XFILLER_1_255 VGND VGND VPWR VPWR sky130_fd_sc_hd__fill_2
XFILLER_49_204 VGND VGND VPWR VPWR sky130_fd_sc_hd__decap_3
XFILLER_103_150 VGND VGND VPWR VPWR sky130_fd_sc_hd__decap_3
XFILLER_89_373 VGND VGND VPWR VPWR sky130_fd_sc_hd__decap_3
XFILLER_104_684 VGND VGND VPWR VPWR sky130_fd_sc_hd__decap_3
XFILLER_77_524 VGND VGND VPWR VPWR sky130_fd_sc_hd__decap_3
XFILLER_103_172 VGND VGND VPWR VPWR sky130_fd_sc_hd__decap_3
XFILLER_49_237 VGND VGND VPWR VPWR sky130_fd_sc_hd__decap_3
XFILLER_106_82 VGND VGND VPWR VPWR sky130_fd_sc_hd__fill_2
XFILLER_92_505 VGND VGND VPWR VPWR sky130_fd_sc_hd__fill_2
XFILLER_64_218 VGND VGND VPWR VPWR sky130_fd_sc_hd__decap_3
XFILLER_18_613 VGND VGND VPWR VPWR sky130_fd_sc_hd__decap_3
XFILLER_57_281 VGND VGND VPWR VPWR sky130_fd_sc_hd__decap_3
XTAP_TAPCELL_ROW_28_630 VGND VPWR sky130_fd_sc_hd__tapvpwrvgnd_1
XFILLER_18_657 VGND VGND VPWR VPWR sky130_fd_sc_hd__decap_3
XFILLER_33_605 VGND VGND VPWR VPWR sky130_fd_sc_hd__decap_3
XFILLER_45_476 VGND VGND VPWR VPWR sky130_fd_sc_hd__decap_3
XFILLER_17_167 VGND VGND VPWR VPWR sky130_fd_sc_hd__fill_1
XTAP_TAPCELL_ROW_86_1388 VGND VPWR sky130_fd_sc_hd__tapvpwrvgnd_1
XFILLER_82_41 VGND VGND VPWR VPWR sky130_fd_sc_hd__decap_3
XFILLER_60_413 VGND VGND VPWR VPWR sky130_fd_sc_hd__fill_1
XTAP_TAPCELL_ROW_56_994 VGND VPWR sky130_fd_sc_hd__tapvpwrvgnd_1
XFILLER_33_638 VGND VGND VPWR VPWR sky130_fd_sc_hd__decap_3
XFILLER_17_189 VGND VGND VPWR VPWR sky130_fd_sc_hd__decap_3
XFILLER_32_137 VGND VGND VPWR VPWR sky130_fd_sc_hd__decap_3
XFILLER_26_690 VGND VGND VPWR VPWR sky130_fd_sc_hd__decap_3
XFILLER_82_74 VGND VGND VPWR VPWR sky130_fd_sc_hd__decap_3
XFILLER_82_85 VGND VGND VPWR VPWR sky130_fd_sc_hd__decap_3
XFILLER_41_671 VGND VGND VPWR VPWR sky130_fd_sc_hd__fill_1
XFILLER_13_362 VGND VGND VPWR VPWR sky130_fd_sc_hd__decap_3
XFILLER_41_682 VGND VGND VPWR VPWR sky130_fd_sc_hd__decap_3
XFILLER_15_90 VGND VGND VPWR VPWR sky130_fd_sc_hd__decap_3
XFILLER_40_170 VGND VGND VPWR VPWR sky130_fd_sc_hd__fill_2
XFILLER_9_399 VGND VGND VPWR VPWR sky130_fd_sc_hd__decap_3
XPHY_EDGE_ROW_81_Left_205 VGND VGND VPWR VPWR sky130_fd_sc_hd__decap_3
XFILLER_5_561 VGND VGND VPWR VPWR sky130_fd_sc_hd__decap_3
XFILLER_5_594 VGND VGND VPWR VPWR sky130_fd_sc_hd__decap_3
X_4220_ _7196_/Q _3966_/S _4261_/A2 _7388_/Q VGND VGND VPWR VPWR _4220_/X sky130_fd_sc_hd__a22o_2
X_4151_ _7019_/Q _4437_/A2 _3935_/S _7202_/Q _4150_/X VGND VGND VPWR VPWR _4151_/X
+ sky130_fd_sc_hd__a221o_2
XFILLER_95_310 VGND VGND VPWR VPWR sky130_fd_sc_hd__decap_3
XFILLER_110_610 VGND VGND VPWR VPWR sky130_fd_sc_hd__decap_3
XFILLER_68_546 VGND VGND VPWR VPWR sky130_fd_sc_hd__decap_3
XFILLER_122_492 VGND VGND VPWR VPWR sky130_fd_sc_hd__decap_3
XFILLER_95_332 VGND VGND VPWR VPWR sky130_fd_sc_hd__decap_3
XFILLER_110_643 VGND VGND VPWR VPWR sky130_fd_sc_hd__fill_1
XFILLER_95_343 VGND VGND VPWR VPWR sky130_fd_sc_hd__fill_1
XFILLER_110_654 VGND VGND VPWR VPWR sky130_fd_sc_hd__decap_3
X_4082_ _4082_/A _4068_/A VGND VGND VPWR VPWR _4082_/X sky130_fd_sc_hd__or2b_2
XFILLER_95_365 VGND VGND VPWR VPWR sky130_fd_sc_hd__decap_3
XFILLER_83_505 VGND VGND VPWR VPWR sky130_fd_sc_hd__decap_3
XFILLER_56_719 VGND VGND VPWR VPWR sky130_fd_sc_hd__decap_3
XFILLER_110_687 VGND VGND VPWR VPWR sky130_fd_sc_hd__decap_3
XPHY_EDGE_ROW_90_Left_214 VGND VGND VPWR VPWR sky130_fd_sc_hd__decap_3
XFILLER_48_281 VGND VGND VPWR VPWR sky130_fd_sc_hd__decap_3
XFILLER_102_29 VGND VGND VPWR VPWR sky130_fd_sc_hd__decap_3
XFILLER_24_616 VGND VGND VPWR VPWR sky130_fd_sc_hd__decap_3
XFILLER_51_402 VGND VGND VPWR VPWR sky130_fd_sc_hd__decap_3
XFILLER_91_582 VGND VGND VPWR VPWR sky130_fd_sc_hd__decap_3
X_4984_ _5099_/A _4619_/Y _4624_/A VGND VGND VPWR VPWR _5031_/B sky130_fd_sc_hd__a21o_2
Xplace273 _3892_/B1 VGND VGND VPWR VPWR _3850_/B1 sky130_fd_sc_hd__buf_2
Xplace284 _3886_/A2 VGND VGND VPWR VPWR _3888_/A2 sky130_fd_sc_hd__buf_2
X_6723_ _6978_/CLK _6723_/D VGND VGND VPWR VPWR _6723_/Q sky130_fd_sc_hd__dfxtp_2
X_3935_ _7372_/Q _4478_/A0 _3935_/S VGND VGND VPWR VPWR _7372_/D sky130_fd_sc_hd__mux2_2
Xplace295 _3890_/B1 VGND VGND VPWR VPWR _3884_/B1 sky130_fd_sc_hd__buf_2
XFILLER_51_479 VGND VGND VPWR VPWR sky130_fd_sc_hd__decap_3
XFILLER_32_660 VGND VGND VPWR VPWR sky130_fd_sc_hd__decap_3
X_6654_ _6654_/A VGND VGND VPWR VPWR _6654_/Y sky130_fd_sc_hd__inv_2
XFILLER_32_693 VGND VGND VPWR VPWR sky130_fd_sc_hd__decap_3
X_3866_ _6696_/Q _6786_/Q _6874_/Q _6922_/Q _3991_/B _3665_/B VGND VGND VPWR VPWR
+ _3866_/X sky130_fd_sc_hd__mux4_2
X_5605_ _7025_/Q _5633_/B VGND VGND VPWR VPWR _7025_/D sky130_fd_sc_hd__or2_2
XFILLER_118_710 VGND VGND VPWR VPWR sky130_fd_sc_hd__decap_3
X_6585_ _6588_/A VGND VGND VPWR VPWR _6585_/Y sky130_fd_sc_hd__inv_2
X_3797_ _6750_/Q _3892_/A2 _3878_/A2 _6732_/Q VGND VGND VPWR VPWR _3797_/X sky130_fd_sc_hd__a22o_2
XFILLER_117_220 VGND VGND VPWR VPWR sky130_fd_sc_hd__fill_1
X_7206_ _7395_/CLK _7206_/D _6486_/Y VGND VGND VPWR VPWR _7206_/Q sky130_fd_sc_hd__dfrtp_2
X_4418_ _7023_/Q _4422_/A2 _4417_/X VGND VGND VPWR VPWR _4425_/C sky130_fd_sc_hd__a21o_2
X_5398_ _5398_/A0 _4997_/X _5398_/S VGND VGND VPWR VPWR _7134_/D sky130_fd_sc_hd__mux2_2
XFILLER_99_671 VGND VGND VPWR VPWR sky130_fd_sc_hd__fill_1
XFILLER_99_682 VGND VGND VPWR VPWR sky130_fd_sc_hd__decap_3
XFILLER_120_429 VGND VGND VPWR VPWR sky130_fd_sc_hd__fill_1
X_7137_ _7395_/CLK _7137_/D _6417_/Y VGND VGND VPWR VPWR _7137_/Q sky130_fd_sc_hd__dfrtp_2
XTAP_TAPCELL_ROW_6_347 VGND VPWR sky130_fd_sc_hd__tapvpwrvgnd_1
X_4349_ _7257_/Q _4356_/A2 _4349_/B1 _7225_/Q _4348_/X VGND VGND VPWR VPWR _4367_/A
+ sky130_fd_sc_hd__a221o_2
XFILLER_86_321 VGND VGND VPWR VPWR sky130_fd_sc_hd__fill_2
XFILLER_101_632 VGND VGND VPWR VPWR sky130_fd_sc_hd__decap_3
XTAP_TAPCELL_ROW_70_1178 VGND VPWR sky130_fd_sc_hd__tapvpwrvgnd_1
X_7068_ _7392_/CLK _7068_/D _6348_/Y VGND VGND VPWR VPWR _7068_/Q sky130_fd_sc_hd__dfrtp_2
XFILLER_101_665 VGND VGND VPWR VPWR sky130_fd_sc_hd__decap_3
XFILLER_86_365 VGND VGND VPWR VPWR sky130_fd_sc_hd__decap_3
XFILLER_101_676 VGND VGND VPWR VPWR sky130_fd_sc_hd__decap_3
XFILLER_100_153 VGND VGND VPWR VPWR sky130_fd_sc_hd__decap_3
XFILLER_74_527 VGND VGND VPWR VPWR sky130_fd_sc_hd__decap_3
XFILLER_100_186 VGND VGND VPWR VPWR sky130_fd_sc_hd__fill_2
XFILLER_27_421 VGND VGND VPWR VPWR sky130_fd_sc_hd__decap_3
XFILLER_100_197 VGND VGND VPWR VPWR sky130_fd_sc_hd__decap_3
XFILLER_39_292 VGND VGND VPWR VPWR sky130_fd_sc_hd__decap_3
XFILLER_36_67 VGND VGND VPWR VPWR sky130_fd_sc_hd__decap_3
XFILLER_27_465 VGND VGND VPWR VPWR sky130_fd_sc_hd__decap_3
XFILLER_82_571 VGND VGND VPWR VPWR sky130_fd_sc_hd__decap_3
XFILLER_54_262 VGND VGND VPWR VPWR sky130_fd_sc_hd__fill_1
XFILLER_42_402 VGND VGND VPWR VPWR sky130_fd_sc_hd__decap_3
XFILLER_70_722 VGND VGND VPWR VPWR sky130_fd_sc_hd__decap_3
XFILLER_15_638 VGND VGND VPWR VPWR sky130_fd_sc_hd__decap_3
XFILLER_54_284 VGND VGND VPWR VPWR sky130_fd_sc_hd__decap_3
XFILLER_42_424 VGND VGND VPWR VPWR sky130_fd_sc_hd__decap_3
XTAP_TAPCELL_ROW_53_953 VGND VPWR sky130_fd_sc_hd__tapvpwrvgnd_1
XFILLER_42_457 VGND VGND VPWR VPWR sky130_fd_sc_hd__fill_2
XFILLER_30_619 VGND VGND VPWR VPWR sky130_fd_sc_hd__decap_3
XFILLER_23_671 VGND VGND VPWR VPWR sky130_fd_sc_hd__fill_1
XFILLER_23_682 VGND VGND VPWR VPWR sky130_fd_sc_hd__decap_3
XFILLER_52_88 VGND VGND VPWR VPWR sky130_fd_sc_hd__decap_3
XFILLER_52_99 VGND VGND VPWR VPWR sky130_fd_sc_hd__fill_2
XFILLER_10_343 VGND VGND VPWR VPWR sky130_fd_sc_hd__decap_3
XFILLER_10_365 VGND VGND VPWR VPWR sky130_fd_sc_hd__decap_3
XFILLER_109_721 VGND VGND VPWR VPWR sky130_fd_sc_hd__decap_3
XFILLER_109_732 VGND VGND VPWR VPWR sky130_fd_sc_hd__decap_3
XFILLER_108_220 VGND VGND VPWR VPWR sky130_fd_sc_hd__decap_3
XFILLER_2_531 VGND VGND VPWR VPWR sky130_fd_sc_hd__fill_1
XFILLER_2_542 VGND VGND VPWR VPWR sky130_fd_sc_hd__decap_3
XFILLER_123_256 VGND VGND VPWR VPWR sky130_fd_sc_hd__decap_3
XFILLER_2_575 VGND VGND VPWR VPWR sky130_fd_sc_hd__decap_3
XFILLER_117_81 VGND VGND VPWR VPWR sky130_fd_sc_hd__decap_3
XFILLER_77_332 VGND VGND VPWR VPWR sky130_fd_sc_hd__decap_3
XFILLER_77_343 VGND VGND VPWR VPWR sky130_fd_sc_hd__decap_3
XFILLER_38_719 VGND VGND VPWR VPWR sky130_fd_sc_hd__decap_3
XTAP_TAPCELL_ROW_88_1406 VGND VPWR sky130_fd_sc_hd__tapvpwrvgnd_1
XTAP_TAPCELL_ROW_88_1417 VGND VPWR sky130_fd_sc_hd__tapvpwrvgnd_1
XFILLER_18_421 VGND VGND VPWR VPWR sky130_fd_sc_hd__decap_3
XFILLER_92_346 VGND VGND VPWR VPWR sky130_fd_sc_hd__decap_3
XFILLER_18_454 VGND VGND VPWR VPWR sky130_fd_sc_hd__decap_3
XFILLER_61_700 VGND VGND VPWR VPWR sky130_fd_sc_hd__decap_3
XFILLER_45_262 VGND VGND VPWR VPWR sky130_fd_sc_hd__decap_3
XFILLER_33_435 VGND VGND VPWR VPWR sky130_fd_sc_hd__decap_3
XFILLER_60_265 VGND VGND VPWR VPWR sky130_fd_sc_hd__fill_2
XFILLER_14_660 VGND VGND VPWR VPWR sky130_fd_sc_hd__decap_3
X_3720_ _6911_/Q _3888_/A2 _3878_/B1 _6903_/Q VGND VGND VPWR VPWR _3720_/X sky130_fd_sc_hd__a22o_2
XFILLER_14_693 VGND VGND VPWR VPWR sky130_fd_sc_hd__decap_3
XFILLER_9_130 VGND VGND VPWR VPWR sky130_fd_sc_hd__decap_3
Xclkbuf_leaf_40_clk clkload0/A VGND VGND VPWR VPWR _7380_/CLK sky130_fd_sc_hd__clkbuf_16
XFILLER_13_192 VGND VGND VPWR VPWR sky130_fd_sc_hd__decap_3
XTAP_TAPCELL_ROW_31_669 VGND VPWR sky130_fd_sc_hd__tapvpwrvgnd_1
XFILLER_119_529 VGND VGND VPWR VPWR sky130_fd_sc_hd__decap_3
XTAP_TAPCELL_ROW_99_1557 VGND VPWR sky130_fd_sc_hd__tapvpwrvgnd_1
X_3651_ _3665_/A _3665_/B VGND VGND VPWR VPWR _3651_/Y sky130_fd_sc_hd__nor2_2
XFILLER_9_185 VGND VGND VPWR VPWR sky130_fd_sc_hd__decap_3
X_6370_ _6370_/A VGND VGND VPWR VPWR _6370_/Y sky130_fd_sc_hd__inv_2
XFILLER_61_3 VGND VGND VPWR VPWR sky130_fd_sc_hd__decap_3
X_3582_ _7348_/Q _4337_/B _3407_/X _7124_/Q VGND VGND VPWR VPWR _3583_/C sky130_fd_sc_hd__a22o_2
X_5321_ _5321_/A0 _4932_/X _5340_/S VGND VGND VPWR VPWR _7170_/D sky130_fd_sc_hd__mux2_2
XFILLER_115_724 VGND VGND VPWR VPWR sky130_fd_sc_hd__decap_3
XFILLER_114_212 VGND VGND VPWR VPWR sky130_fd_sc_hd__decap_3
XFILLER_114_256 VGND VGND VPWR VPWR sky130_fd_sc_hd__decap_3
XTAP_TAPCELL_ROW_110_1702 VGND VPWR sky130_fd_sc_hd__tapvpwrvgnd_1
XFILLER_88_619 VGND VGND VPWR VPWR sky130_fd_sc_hd__decap_3
X_4203_ _4203_/A _4203_/B _4203_/C VGND VGND VPWR VPWR _4203_/X sky130_fd_sc_hd__and3_2
XTAP_TAPCELL_ROW_3_306 VGND VPWR sky130_fd_sc_hd__tapvpwrvgnd_1
X_4134_ _7020_/Q _4437_/A2 _3958_/S _7203_/Q _4133_/X VGND VGND VPWR VPWR _4134_/X
+ sky130_fd_sc_hd__a221o_2
XFILLER_96_663 VGND VGND VPWR VPWR sky130_fd_sc_hd__decap_3
XFILLER_68_365 VGND VGND VPWR VPWR sky130_fd_sc_hd__decap_3
XFILLER_28_218 VGND VGND VPWR VPWR sky130_fd_sc_hd__decap_3
XFILLER_96_696 VGND VGND VPWR VPWR sky130_fd_sc_hd__decap_3
X_4065_ _7052_/Q _4488_/S _4437_/B1 _7404_/Q _4064_/X VGND VGND VPWR VPWR _4065_/X
+ sky130_fd_sc_hd__a221o_2
XFILLER_83_335 VGND VGND VPWR VPWR sky130_fd_sc_hd__fill_1
XFILLER_113_39 VGND VGND VPWR VPWR sky130_fd_sc_hd__decap_3
XFILLER_83_346 VGND VGND VPWR VPWR sky130_fd_sc_hd__decap_3
XTAP_TAPCELL_ROW_39_769 VGND VPWR sky130_fd_sc_hd__tapvpwrvgnd_1
XFILLER_71_519 VGND VGND VPWR VPWR sky130_fd_sc_hd__decap_3
XFILLER_36_240 VGND VGND VPWR VPWR sky130_fd_sc_hd__decap_3
XTAP_TAPCELL_ROW_108_1675 VGND VPWR sky130_fd_sc_hd__tapvpwrvgnd_1
XFILLER_36_262 VGND VGND VPWR VPWR sky130_fd_sc_hd__fill_2
XFILLER_52_722 VGND VGND VPWR VPWR sky130_fd_sc_hd__decap_3
XFILLER_24_413 VGND VGND VPWR VPWR sky130_fd_sc_hd__decap_3
XFILLER_24_424 VGND VGND VPWR VPWR sky130_fd_sc_hd__decap_3
XFILLER_36_295 VGND VGND VPWR VPWR sky130_fd_sc_hd__decap_3
XTAP_TAPCELL_ROW_121_1842 VGND VPWR sky130_fd_sc_hd__tapvpwrvgnd_1
XFILLER_24_468 VGND VGND VPWR VPWR sky130_fd_sc_hd__decap_3
XFILLER_12_619 VGND VGND VPWR VPWR sky130_fd_sc_hd__decap_3
XTAP_TAPCELL_ROW_50_912 VGND VPWR sky130_fd_sc_hd__tapvpwrvgnd_1
X_4967_ _4967_/A _4967_/B VGND VGND VPWR VPWR _4967_/X sky130_fd_sc_hd__or2_2
XFILLER_51_276 VGND VGND VPWR VPWR sky130_fd_sc_hd__decap_3
XTAP_TAPCELL_ROW_50_923 VGND VPWR sky130_fd_sc_hd__tapvpwrvgnd_1
XFILLER_51_298 VGND VGND VPWR VPWR sky130_fd_sc_hd__fill_1
X_3918_ _6915_/Q _3926_/A2 _3926_/B1 _6779_/Q _3917_/X VGND VGND VPWR VPWR _3918_/X
+ sky130_fd_sc_hd__a221o_2
X_6706_ _7401_/CLK _6706_/D VGND VGND VPWR VPWR _6706_/Q sky130_fd_sc_hd__dfxtp_2
Xclkbuf_leaf_31_clk clkload1/A VGND VGND VPWR VPWR _7354_/CLK sky130_fd_sc_hd__clkbuf_16
X_4898_ _4832_/A _3756_/X _4897_/X _5010_/A VGND VGND VPWR VPWR _4898_/X sky130_fd_sc_hd__a211o_2
X_6637_ _6637_/A VGND VGND VPWR VPWR _6637_/Y sky130_fd_sc_hd__inv_2
XFILLER_20_663 VGND VGND VPWR VPWR sky130_fd_sc_hd__decap_3
X_3849_ _6859_/Q _3651_/Y _3891_/B1 _6899_/Q _3848_/X VGND VGND VPWR VPWR _3849_/X
+ sky130_fd_sc_hd__a221o_2
XFILLER_20_696 VGND VGND VPWR VPWR sky130_fd_sc_hd__decap_3
XTAP_TAPCELL_ROW_59_1029 VGND VPWR sky130_fd_sc_hd__tapvpwrvgnd_1
X_6568_ _6568_/A VGND VGND VPWR VPWR _6568_/Y sky130_fd_sc_hd__inv_2
XFILLER_118_551 VGND VGND VPWR VPWR sky130_fd_sc_hd__decap_3
XFILLER_98_29 VGND VGND VPWR VPWR sky130_fd_sc_hd__decap_3
XFILLER_106_713 VGND VGND VPWR VPWR sky130_fd_sc_hd__decap_3
XFILLER_118_584 VGND VGND VPWR VPWR sky130_fd_sc_hd__decap_3
XFILLER_105_201 VGND VGND VPWR VPWR sky130_fd_sc_hd__decap_3
XFILLER_118_595 VGND VGND VPWR VPWR sky130_fd_sc_hd__decap_3
X_6499_ _6566_/A VGND VGND VPWR VPWR _6499_/Y sky130_fd_sc_hd__inv_2
XFILLER_105_234 VGND VGND VPWR VPWR sky130_fd_sc_hd__decap_3
XTAP_TAPCELL_ROW_72_1207 VGND VPWR sky130_fd_sc_hd__tapvpwrvgnd_1
Xoutput471 _5656_/C VGND VGND VPWR VPWR alu_result_out[19] sky130_fd_sc_hd__clkdlybuf4s25_1
XFILLER_121_727 VGND VGND VPWR VPWR sky130_fd_sc_hd__fill_1
Xoutput482 _5653_/Y VGND VGND VPWR VPWR alu_result_out[29] sky130_fd_sc_hd__clkdlybuf4s25_1
XFILLER_78_118 VGND VGND VPWR VPWR sky130_fd_sc_hd__decap_3
Xoutput493 _3378_/A VGND VGND VPWR VPWR instruction_out[10] sky130_fd_sc_hd__clkdlybuf4s25_1
XFILLER_120_215 VGND VGND VPWR VPWR sky130_fd_sc_hd__fill_1
XFILLER_120_237 VGND VGND VPWR VPWR sky130_fd_sc_hd__decap_3
XFILLER_87_641 VGND VGND VPWR VPWR sky130_fd_sc_hd__decap_3
XFILLER_59_343 VGND VGND VPWR VPWR sky130_fd_sc_hd__decap_3
XFILLER_101_440 VGND VGND VPWR VPWR sky130_fd_sc_hd__decap_3
XFILLER_47_505 VGND VGND VPWR VPWR sky130_fd_sc_hd__decap_3
XFILLER_87_685 VGND VGND VPWR VPWR sky130_fd_sc_hd__decap_3
XFILLER_74_302 VGND VGND VPWR VPWR sky130_fd_sc_hd__decap_3
XFILLER_19_218 VGND VGND VPWR VPWR sky130_fd_sc_hd__decap_3
XFILLER_86_184 VGND VGND VPWR VPWR sky130_fd_sc_hd__decap_3
XFILLER_74_357 VGND VGND VPWR VPWR sky130_fd_sc_hd__decap_3
XFILLER_74_368 VGND VGND VPWR VPWR sky130_fd_sc_hd__decap_3
XFILLER_43_700 VGND VGND VPWR VPWR sky130_fd_sc_hd__decap_3
XFILLER_27_251 VGND VGND VPWR VPWR sky130_fd_sc_hd__decap_3
XFILLER_15_402 VGND VGND VPWR VPWR sky130_fd_sc_hd__decap_3
XFILLER_27_284 VGND VGND VPWR VPWR sky130_fd_sc_hd__decap_3
XFILLER_42_221 VGND VGND VPWR VPWR sky130_fd_sc_hd__decap_3
XTAP_TAPCELL_ROW_83_1347 VGND VPWR sky130_fd_sc_hd__tapvpwrvgnd_1
XFILLER_30_427 VGND VGND VPWR VPWR sky130_fd_sc_hd__fill_1
XFILLER_42_298 VGND VGND VPWR VPWR sky130_fd_sc_hd__decap_3
XFILLER_8_27 VGND VGND VPWR VPWR sky130_fd_sc_hd__fill_1
XFILLER_30_449 VGND VGND VPWR VPWR sky130_fd_sc_hd__decap_3
Xclkbuf_leaf_22_clk clkload3/A VGND VGND VPWR VPWR _7368_/CLK sky130_fd_sc_hd__clkbuf_16
XFILLER_11_641 VGND VGND VPWR VPWR sky130_fd_sc_hd__decap_3
XFILLER_7_612 VGND VGND VPWR VPWR sky130_fd_sc_hd__decap_3
XFILLER_7_623 VGND VGND VPWR VPWR sky130_fd_sc_hd__decap_3
XFILLER_11_685 VGND VGND VPWR VPWR sky130_fd_sc_hd__decap_3
Xwire565 _6621_/A VGND VGND VPWR VPWR _6588_/A sky130_fd_sc_hd__buf_2
XFILLER_7_656 VGND VGND VPWR VPWR sky130_fd_sc_hd__decap_3
XFILLER_6_133 VGND VGND VPWR VPWR sky130_fd_sc_hd__decap_3
XFILLER_109_540 VGND VGND VPWR VPWR sky130_fd_sc_hd__decap_3
XFILLER_109_573 VGND VGND VPWR VPWR sky130_fd_sc_hd__decap_3
XFILLER_6_188 VGND VGND VPWR VPWR sky130_fd_sc_hd__decap_3
XTAP_TAPCELL_ROW_94_1487 VGND VPWR sky130_fd_sc_hd__tapvpwrvgnd_1
XFILLER_112_716 VGND VGND VPWR VPWR sky130_fd_sc_hd__decap_3
XFILLER_97_416 VGND VGND VPWR VPWR sky130_fd_sc_hd__decap_3
XFILLER_111_215 VGND VGND VPWR VPWR sky130_fd_sc_hd__decap_3
XFILLER_97_449 VGND VGND VPWR VPWR sky130_fd_sc_hd__decap_3
XFILLER_111_259 VGND VGND VPWR VPWR sky130_fd_sc_hd__decap_3
XFILLER_78_663 VGND VGND VPWR VPWR sky130_fd_sc_hd__decap_3
XFILLER_93_600 VGND VGND VPWR VPWR sky130_fd_sc_hd__decap_3
XFILLER_77_162 VGND VGND VPWR VPWR sky130_fd_sc_hd__decap_3
XFILLER_65_302 VGND VGND VPWR VPWR sky130_fd_sc_hd__decap_3
XFILLER_78_696 VGND VGND VPWR VPWR sky130_fd_sc_hd__decap_3
XFILLER_77_184 VGND VGND VPWR VPWR sky130_fd_sc_hd__decap_3
XFILLER_93_644 VGND VGND VPWR VPWR sky130_fd_sc_hd__decap_3
XFILLER_65_346 VGND VGND VPWR VPWR sky130_fd_sc_hd__decap_3
XFILLER_65_368 VGND VGND VPWR VPWR sky130_fd_sc_hd__decap_3
XFILLER_93_688 VGND VGND VPWR VPWR sky130_fd_sc_hd__decap_3
XFILLER_18_251 VGND VGND VPWR VPWR sky130_fd_sc_hd__fill_1
XTAP_TAPCELL_ROW_36_739 VGND VPWR sky130_fd_sc_hd__tapvpwrvgnd_1
XFILLER_34_722 VGND VGND VPWR VPWR sky130_fd_sc_hd__decap_3
XFILLER_46_593 VGND VGND VPWR VPWR sky130_fd_sc_hd__decap_3
XFILLER_73_390 VGND VGND VPWR VPWR sky130_fd_sc_hd__fill_2
XFILLER_33_243 VGND VGND VPWR VPWR sky130_fd_sc_hd__decap_3
X_4821_ _4832_/A _3704_/X _4819_/X _5010_/A VGND VGND VPWR VPWR _4821_/X sky130_fd_sc_hd__a211o_2
XTAP_TAPCELL_ROW_16_474 VGND VPWR sky130_fd_sc_hd__tapvpwrvgnd_1
XFILLER_21_438 VGND VGND VPWR VPWR sky130_fd_sc_hd__decap_3
X_4752_ _4997_/A1 _7006_/D _4751_/Y VGND VGND VPWR VPWR _4752_/X sky130_fd_sc_hd__a21o_2
XFILLER_21_449 VGND VGND VPWR VPWR sky130_fd_sc_hd__decap_3
Xclkbuf_leaf_13_clk clkload2/A VGND VGND VPWR VPWR _7403_/CLK sky130_fd_sc_hd__clkbuf_16
X_3703_ _6938_/Q _3898_/A2 _3759_/A2 _6802_/Q VGND VGND VPWR VPWR _3703_/X sky130_fd_sc_hd__a22o_2
X_4683_ _6997_/Q _6998_/Q _4690_/B VGND VGND VPWR VPWR _4683_/X sky130_fd_sc_hd__o21a_2
X_6422_ _6654_/A VGND VGND VPWR VPWR _6422_/Y sky130_fd_sc_hd__inv_2
X_3634_ _3636_/B _3631_/Y _3632_/X _3633_/Y VGND VGND VPWR VPWR _3634_/Y sky130_fd_sc_hd__o211ai_4
XFILLER_108_17 VGND VGND VPWR VPWR sky130_fd_sc_hd__decap_3
X_6353_ _6684_/A VGND VGND VPWR VPWR _6353_/Y sky130_fd_sc_hd__inv_2
X_3565_ _3469_/A _3469_/B _3564_/X _3449_/A VGND VGND VPWR VPWR _5648_/B sky130_fd_sc_hd__o211a_2
XFILLER_115_532 VGND VGND VPWR VPWR sky130_fd_sc_hd__decap_3
X_5304_ _5304_/A0 _4792_/X _5315_/S VGND VGND VPWR VPWR _7178_/D sky130_fd_sc_hd__mux2_2
X_6284_ _6462_/A VGND VGND VPWR VPWR _6284_/Y sky130_fd_sc_hd__inv_2
X_3496_ _7215_/Q _4307_/A2 _5140_/S _7279_/Q _3495_/X VGND VGND VPWR VPWR _3496_/X
+ sky130_fd_sc_hd__a221o_2
XFILLER_88_416 VGND VGND VPWR VPWR sky130_fd_sc_hd__decap_3
XFILLER_115_576 VGND VGND VPWR VPWR sky130_fd_sc_hd__decap_3
XFILLER_88_427 VGND VGND VPWR VPWR sky130_fd_sc_hd__fill_2
XFILLER_103_727 VGND VGND VPWR VPWR sky130_fd_sc_hd__fill_1
XFILLER_102_204 VGND VGND VPWR VPWR sky130_fd_sc_hd__decap_3
XFILLER_69_641 VGND VGND VPWR VPWR sky130_fd_sc_hd__decap_3
XFILLER_29_505 VGND VGND VPWR VPWR sky130_fd_sc_hd__fill_2
XFILLER_69_685 VGND VGND VPWR VPWR sky130_fd_sc_hd__decap_3
XFILLER_96_471 VGND VGND VPWR VPWR sky130_fd_sc_hd__fill_2
XFILLER_84_622 VGND VGND VPWR VPWR sky130_fd_sc_hd__decap_3
X_4117_ _4205_/A _4117_/B _4117_/C VGND VGND VPWR VPWR _4117_/Y sky130_fd_sc_hd__nand3_2
XFILLER_56_335 VGND VGND VPWR VPWR sky130_fd_sc_hd__decap_3
X_5097_ _6985_/Q _5120_/A VGND VGND VPWR VPWR _5098_/B sky130_fd_sc_hd__nor2_2
XFILLER_84_666 VGND VGND VPWR VPWR sky130_fd_sc_hd__decap_3
XFILLER_56_368 VGND VGND VPWR VPWR sky130_fd_sc_hd__decap_3
X_4048_ _7117_/Q _4434_/A2 _4434_/B1 _7149_/Q VGND VGND VPWR VPWR _4048_/X sky130_fd_sc_hd__a22o_2
XFILLER_83_165 VGND VGND VPWR VPWR sky130_fd_sc_hd__decap_3
XFILLER_71_305 VGND VGND VPWR VPWR sky130_fd_sc_hd__decap_3
XFILLER_44_519 VGND VGND VPWR VPWR sky130_fd_sc_hd__decap_3
XFILLER_25_700 VGND VGND VPWR VPWR sky130_fd_sc_hd__decap_3
XFILLER_84_699 VGND VGND VPWR VPWR sky130_fd_sc_hd__fill_1
XFILLER_24_232 VGND VGND VPWR VPWR sky130_fd_sc_hd__fill_1
XFILLER_24_265 VGND VGND VPWR VPWR sky130_fd_sc_hd__decap_3
XFILLER_40_725 VGND VGND VPWR VPWR sky130_fd_sc_hd__decap_3
XFILLER_12_427 VGND VGND VPWR VPWR sky130_fd_sc_hd__fill_2
XFILLER_24_298 VGND VGND VPWR VPWR sky130_fd_sc_hd__decap_3
XFILLER_12_449 VGND VGND VPWR VPWR sky130_fd_sc_hd__decap_3
XFILLER_33_57 VGND VGND VPWR VPWR sky130_fd_sc_hd__fill_2
XFILLER_20_493 VGND VGND VPWR VPWR sky130_fd_sc_hd__fill_1
XFILLER_4_604 VGND VGND VPWR VPWR sky130_fd_sc_hd__decap_3
XFILLER_4_637 VGND VGND VPWR VPWR sky130_fd_sc_hd__decap_3
XFILLER_4_648 VGND VGND VPWR VPWR sky130_fd_sc_hd__decap_3
XFILLER_109_3 VGND VGND VPWR VPWR sky130_fd_sc_hd__decap_3
XFILLER_106_554 VGND VGND VPWR VPWR sky130_fd_sc_hd__decap_3
XFILLER_79_405 VGND VGND VPWR VPWR sky130_fd_sc_hd__decap_3
XFILLER_3_169 VGND VGND VPWR VPWR sky130_fd_sc_hd__decap_3
XFILLER_106_587 VGND VGND VPWR VPWR sky130_fd_sc_hd__fill_1
XFILLER_106_598 VGND VGND VPWR VPWR sky130_fd_sc_hd__decap_3
XFILLER_79_449 VGND VGND VPWR VPWR sky130_fd_sc_hd__decap_3
XFILLER_121_535 VGND VGND VPWR VPWR sky130_fd_sc_hd__decap_3
XFILLER_121_579 VGND VGND VPWR VPWR sky130_fd_sc_hd__decap_3
XFILLER_75_600 VGND VGND VPWR VPWR sky130_fd_sc_hd__decap_3
XFILLER_47_313 VGND VGND VPWR VPWR sky130_fd_sc_hd__decap_3
XFILLER_59_184 VGND VGND VPWR VPWR sky130_fd_sc_hd__decap_3
XFILLER_101_270 VGND VGND VPWR VPWR sky130_fd_sc_hd__decap_3
XFILLER_75_644 VGND VGND VPWR VPWR sky130_fd_sc_hd__decap_3
XFILLER_74_121 VGND VGND VPWR VPWR sky130_fd_sc_hd__decap_3
XFILLER_47_346 VGND VGND VPWR VPWR sky130_fd_sc_hd__decap_3
XFILLER_101_292 VGND VGND VPWR VPWR sky130_fd_sc_hd__decap_3
XFILLER_114_71 VGND VGND VPWR VPWR sky130_fd_sc_hd__decap_3
XFILLER_75_688 VGND VGND VPWR VPWR sky130_fd_sc_hd__decap_3
XFILLER_74_42 VGND VGND VPWR VPWR sky130_fd_sc_hd__fill_1
XFILLER_74_165 VGND VGND VPWR VPWR sky130_fd_sc_hd__decap_3
XFILLER_90_625 VGND VGND VPWR VPWR sky130_fd_sc_hd__decap_3
XFILLER_28_571 VGND VGND VPWR VPWR sky130_fd_sc_hd__decap_3
XFILLER_16_722 VGND VGND VPWR VPWR sky130_fd_sc_hd__decap_3
XFILLER_90_669 VGND VGND VPWR VPWR sky130_fd_sc_hd__decap_3
XFILLER_43_541 VGND VGND VPWR VPWR sky130_fd_sc_hd__decap_3
XFILLER_31_703 VGND VGND VPWR VPWR sky130_fd_sc_hd__decap_3
XFILLER_70_360 VGND VGND VPWR VPWR sky130_fd_sc_hd__decap_3
XFILLER_15_265 VGND VGND VPWR VPWR sky130_fd_sc_hd__decap_3
XFILLER_70_371 VGND VGND VPWR VPWR sky130_fd_sc_hd__fill_1
XFILLER_95_9 VGND VGND VPWR VPWR sky130_fd_sc_hd__fill_1
XFILLER_43_596 VGND VGND VPWR VPWR sky130_fd_sc_hd__decap_3
XFILLER_30_213 VGND VGND VPWR VPWR sky130_fd_sc_hd__decap_3
XTAP_TAPCELL_ROW_13_433 VGND VPWR sky130_fd_sc_hd__tapvpwrvgnd_1
XFILLER_90_96 VGND VGND VPWR VPWR sky130_fd_sc_hd__decap_3
XFILLER_30_268 VGND VGND VPWR VPWR sky130_fd_sc_hd__decap_3
XFILLER_11_460 VGND VGND VPWR VPWR sky130_fd_sc_hd__decap_3
XTAP_TAPCELL_ROW_41_797 VGND VPWR sky130_fd_sc_hd__tapvpwrvgnd_1
XTAP_TAPCELL_ROW_96_1516 VGND VPWR sky130_fd_sc_hd__tapvpwrvgnd_1
XFILLER_7_442 VGND VGND VPWR VPWR sky130_fd_sc_hd__decap_3
XFILLER_7_497 VGND VGND VPWR VPWR sky130_fd_sc_hd__fill_1
X_3350_ _5129_/B _3350_/B VGND VGND VPWR VPWR _3350_/Y sky130_fd_sc_hd__nor2_2
XFILLER_98_725 VGND VGND VPWR VPWR sky130_fd_sc_hd__decap_3
XFILLER_112_513 VGND VGND VPWR VPWR sky130_fd_sc_hd__decap_3
XFILLER_112_557 VGND VGND VPWR VPWR sky130_fd_sc_hd__decap_3
X_5020_ _5020_/A _5020_/B _4373_/Y VGND VGND VPWR VPWR _5020_/X sky130_fd_sc_hd__or3b_2
XFILLER_100_719 VGND VGND VPWR VPWR sky130_fd_sc_hd__decap_3
Xhold1109 _7159_/Q VGND VGND VPWR VPWR _5344_/A0 sky130_fd_sc_hd__dlygate4sd3_1
Xclkbuf_leaf_2_clk clkbuf_leaf_2_clk/A VGND VGND VPWR VPWR _7215_/CLK sky130_fd_sc_hd__clkbuf_16
XFILLER_66_600 VGND VGND VPWR VPWR sky130_fd_sc_hd__decap_3
XPHY_EDGE_ROW_119_Right_119 VGND VGND VPWR VPWR sky130_fd_sc_hd__decap_3
XFILLER_66_633 VGND VGND VPWR VPWR sky130_fd_sc_hd__decap_3
XFILLER_66_666 VGND VGND VPWR VPWR sky130_fd_sc_hd__decap_3
XFILLER_38_357 VGND VGND VPWR VPWR sky130_fd_sc_hd__decap_3
XFILLER_93_452 VGND VGND VPWR VPWR sky130_fd_sc_hd__decap_3
XFILLER_81_603 VGND VGND VPWR VPWR sky130_fd_sc_hd__decap_3
XFILLER_53_305 VGND VGND VPWR VPWR sky130_fd_sc_hd__decap_3
X_6971_ clkload5/A _6971_/D VGND VGND VPWR VPWR _6971_/Q sky130_fd_sc_hd__dfxtp_2
XFILLER_66_699 VGND VGND VPWR VPWR sky130_fd_sc_hd__fill_1
XFILLER_81_647 VGND VGND VPWR VPWR sky130_fd_sc_hd__decap_3
XFILLER_19_582 VGND VGND VPWR VPWR sky130_fd_sc_hd__decap_3
XTAP_TAPCELL_ROW_105_1634 VGND VPWR sky130_fd_sc_hd__tapvpwrvgnd_1
XFILLER_80_135 VGND VGND VPWR VPWR sky130_fd_sc_hd__decap_3
XFILLER_80_157 VGND VGND VPWR VPWR sky130_fd_sc_hd__decap_3
XFILLER_34_552 VGND VGND VPWR VPWR sky130_fd_sc_hd__decap_3
XFILLER_80_168 VGND VGND VPWR VPWR sky130_fd_sc_hd__decap_3
XFILLER_110_18 VGND VGND VPWR VPWR sky130_fd_sc_hd__decap_3
XFILLER_110_29 VGND VGND VPWR VPWR sky130_fd_sc_hd__decap_3
XFILLER_61_360 VGND VGND VPWR VPWR sky130_fd_sc_hd__decap_3
XFILLER_22_725 VGND VGND VPWR VPWR sky130_fd_sc_hd__decap_3
XFILLER_21_202 VGND VGND VPWR VPWR sky130_fd_sc_hd__decap_3
X_4804_ _4804_/A _4804_/B VGND VGND VPWR VPWR _4804_/X sky130_fd_sc_hd__or2_2
XFILLER_61_393 VGND VGND VPWR VPWR sky130_fd_sc_hd__fill_1
XFILLER_21_246 VGND VGND VPWR VPWR sky130_fd_sc_hd__decap_3
X_4735_ _4735_/A0 _4734_/X _4837_/S VGND VGND VPWR VPWR _7277_/D sky130_fd_sc_hd__mux2_2
XFILLER_21_279 VGND VGND VPWR VPWR sky130_fd_sc_hd__fill_1
XFILLER_119_134 VGND VGND VPWR VPWR sky130_fd_sc_hd__decap_3
XFILLER_119_27 VGND VGND VPWR VPWR sky130_fd_sc_hd__decap_3
X_4666_ _6997_/Q _4667_/B VGND VGND VPWR VPWR _4908_/A sky130_fd_sc_hd__xnor2_2
XFILLER_119_167 VGND VGND VPWR VPWR sky130_fd_sc_hd__fill_1
X_6405_ _6596_/A VGND VGND VPWR VPWR _6405_/Y sky130_fd_sc_hd__inv_2
X_3617_ _4614_/C _3616_/B _5146_/B1 VGND VGND VPWR VPWR _3617_/X sky130_fd_sc_hd__o21a_2
Xhold910 _6687_/Q VGND VGND VPWR VPWR hold910/X sky130_fd_sc_hd__dlygate4sd3_1
X_7385_ _7386_/CLK _7385_/D _6665_/Y VGND VGND VPWR VPWR _7385_/Q sky130_fd_sc_hd__dfrtp_2
X_4597_ _7282_/Q _5140_/A0 _4601_/S VGND VGND VPWR VPWR _7282_/D sky130_fd_sc_hd__mux2_2
Xhold921 _6709_/Q VGND VGND VPWR VPWR hold921/X sky130_fd_sc_hd__dlygate4sd3_1
Xhold932 _6710_/Q VGND VGND VPWR VPWR hold932/X sky130_fd_sc_hd__dlygate4sd3_1
Xhold943 _6691_/Q VGND VGND VPWR VPWR hold943/X sky130_fd_sc_hd__dlygate4sd3_1
XTAP_TAPCELL_ROW_116_1774 VGND VPWR sky130_fd_sc_hd__tapvpwrvgnd_1
X_6336_ _6660_/A VGND VGND VPWR VPWR _6336_/Y sky130_fd_sc_hd__inv_2
Xhold954 _7052_/Q VGND VGND VPWR VPWR hold954/X sky130_fd_sc_hd__dlygate4sd3_1
XFILLER_89_703 VGND VGND VPWR VPWR sky130_fd_sc_hd__decap_3
X_3548_ _3621_/A _4938_/A _5114_/A VGND VGND VPWR VPWR _4948_/A sky130_fd_sc_hd__or3_2
Xhold965 _7401_/Q VGND VGND VPWR VPWR hold965/X sky130_fd_sc_hd__dlygate4sd3_1
XFILLER_115_362 VGND VGND VPWR VPWR sky130_fd_sc_hd__decap_3
Xhold976 _7379_/Q VGND VGND VPWR VPWR hold976/X sky130_fd_sc_hd__dlygate4sd3_1
XFILLER_1_629 VGND VGND VPWR VPWR sky130_fd_sc_hd__decap_3
XFILLER_103_513 VGND VGND VPWR VPWR sky130_fd_sc_hd__decap_3
Xhold987 _7038_/Q VGND VGND VPWR VPWR hold987/X sky130_fd_sc_hd__dlygate4sd3_1
Xhold998 _7271_/Q VGND VGND VPWR VPWR hold998/X sky130_fd_sc_hd__dlygate4sd3_1
X_6267_ _6684_/A VGND VGND VPWR VPWR _6267_/Y sky130_fd_sc_hd__inv_2
X_3479_ _7152_/Q _4352_/B1 _3478_/X VGND VGND VPWR VPWR _3482_/A sky130_fd_sc_hd__a21o_2
XFILLER_103_579 VGND VGND VPWR VPWR sky130_fd_sc_hd__decap_3
XFILLER_57_611 VGND VGND VPWR VPWR sky130_fd_sc_hd__decap_3
XFILLER_28_35 VGND VGND VPWR VPWR sky130_fd_sc_hd__fill_2
X_5149_ _5145_/A _4852_/A _5147_/X _5148_/X VGND VGND VPWR VPWR _5149_/Y sky130_fd_sc_hd__o211ai_2
XFILLER_57_644 VGND VGND VPWR VPWR sky130_fd_sc_hd__decap_3
XFILLER_96_290 VGND VGND VPWR VPWR sky130_fd_sc_hd__decap_3
XFILLER_56_121 VGND VGND VPWR VPWR sky130_fd_sc_hd__decap_3
XFILLER_28_79 VGND VGND VPWR VPWR sky130_fd_sc_hd__decap_3
XFILLER_57_688 VGND VGND VPWR VPWR sky130_fd_sc_hd__decap_3
XFILLER_72_625 VGND VGND VPWR VPWR sky130_fd_sc_hd__decap_3
XTAP_TAPCELL_ROW_67_1139 VGND VPWR sky130_fd_sc_hd__tapvpwrvgnd_1
XFILLER_72_669 VGND VGND VPWR VPWR sky130_fd_sc_hd__decap_3
XFILLER_71_157 VGND VGND VPWR VPWR sky130_fd_sc_hd__fill_1
XFILLER_44_45 VGND VGND VPWR VPWR sky130_fd_sc_hd__fill_1
XFILLER_13_703 VGND VGND VPWR VPWR sky130_fd_sc_hd__decap_3
XTAP_TAPCELL_ROW_80_1306 VGND VPWR sky130_fd_sc_hd__tapvpwrvgnd_1
XFILLER_52_371 VGND VGND VPWR VPWR sky130_fd_sc_hd__fill_2
XFILLER_25_585 VGND VGND VPWR VPWR sky130_fd_sc_hd__decap_3
XFILLER_40_522 VGND VGND VPWR VPWR sky130_fd_sc_hd__decap_3
XFILLER_9_718 VGND VGND VPWR VPWR sky130_fd_sc_hd__decap_3
XFILLER_100_40 VGND VGND VPWR VPWR sky130_fd_sc_hd__decap_3
XFILLER_9_729 VGND VGND VPWR VPWR sky130_fd_sc_hd__decap_3
XFILLER_100_62 VGND VGND VPWR VPWR sky130_fd_sc_hd__fill_2
XFILLER_12_279 VGND VGND VPWR VPWR sky130_fd_sc_hd__decap_3
XFILLER_100_73 VGND VGND VPWR VPWR sky130_fd_sc_hd__decap_3
XTAP_TAPCELL_ROW_10_403 VGND VPWR sky130_fd_sc_hd__tapvpwrvgnd_1
XFILLER_60_88 VGND VGND VPWR VPWR sky130_fd_sc_hd__decap_3
XTAP_TAPCELL_ROW_78_1279 VGND VPWR sky130_fd_sc_hd__tapvpwrvgnd_1
XFILLER_106_340 VGND VGND VPWR VPWR sky130_fd_sc_hd__decap_3
XFILLER_4_467 VGND VGND VPWR VPWR sky130_fd_sc_hd__decap_3
XFILLER_69_42 VGND VGND VPWR VPWR sky130_fd_sc_hd__decap_3
XTAP_TAPCELL_ROW_91_1446 VGND VPWR sky130_fd_sc_hd__tapvpwrvgnd_1
XFILLER_79_213 VGND VGND VPWR VPWR sky130_fd_sc_hd__decap_3
XFILLER_79_235 VGND VGND VPWR VPWR sky130_fd_sc_hd__decap_3
XFILLER_95_706 VGND VGND VPWR VPWR sky130_fd_sc_hd__decap_3
XFILLER_79_268 VGND VGND VPWR VPWR sky130_fd_sc_hd__fill_1
XFILLER_67_408 VGND VGND VPWR VPWR sky130_fd_sc_hd__fill_1
XFILLER_79_279 VGND VGND VPWR VPWR sky130_fd_sc_hd__fill_1
XFILLER_0_662 VGND VGND VPWR VPWR sky130_fd_sc_hd__decap_3
XFILLER_48_600 VGND VGND VPWR VPWR sky130_fd_sc_hd__decap_3
XFILLER_94_227 VGND VGND VPWR VPWR sky130_fd_sc_hd__decap_3
XFILLER_0_684 VGND VGND VPWR VPWR sky130_fd_sc_hd__decap_3
XFILLER_48_633 VGND VGND VPWR VPWR sky130_fd_sc_hd__decap_3
XFILLER_85_63 VGND VGND VPWR VPWR sky130_fd_sc_hd__decap_3
XFILLER_75_452 VGND VGND VPWR VPWR sky130_fd_sc_hd__fill_1
XFILLER_48_666 VGND VGND VPWR VPWR sky130_fd_sc_hd__decap_3
XFILLER_85_85 VGND VGND VPWR VPWR sky130_fd_sc_hd__decap_3
XFILLER_47_154 VGND VGND VPWR VPWR sky130_fd_sc_hd__decap_3
XTAP_TAPCELL_ROW_18_503 VGND VPWR sky130_fd_sc_hd__tapvpwrvgnd_1
XFILLER_48_699 VGND VGND VPWR VPWR sky130_fd_sc_hd__fill_1
XFILLER_63_647 VGND VGND VPWR VPWR sky130_fd_sc_hd__decap_3
XFILLER_62_135 VGND VGND VPWR VPWR sky130_fd_sc_hd__decap_3
XFILLER_16_530 VGND VGND VPWR VPWR sky130_fd_sc_hd__fill_2
XTAP_TAPCELL_ROW_46_867 VGND VPWR sky130_fd_sc_hd__tapvpwrvgnd_1
XFILLER_16_552 VGND VGND VPWR VPWR sky130_fd_sc_hd__decap_3
XFILLER_90_477 VGND VGND VPWR VPWR sky130_fd_sc_hd__fill_2
XFILLER_90_488 VGND VGND VPWR VPWR sky130_fd_sc_hd__decap_3
XFILLER_31_511 VGND VGND VPWR VPWR sky130_fd_sc_hd__fill_1
XFILLER_16_585 VGND VGND VPWR VPWR sky130_fd_sc_hd__decap_3
XFILLER_71_691 VGND VGND VPWR VPWR sky130_fd_sc_hd__decap_3
XTAP_TAPCELL_ROW_100_1564 VGND VPWR sky130_fd_sc_hd__tapvpwrvgnd_1
XFILLER_31_588 VGND VGND VPWR VPWR sky130_fd_sc_hd__decap_3
X_4520_ _4520_/A0 _7287_/Q _4520_/S VGND VGND VPWR VPWR _7319_/D sky130_fd_sc_hd__mux2_2
XFILLER_7_261 VGND VGND VPWR VPWR sky130_fd_sc_hd__fill_1
XFILLER_117_638 VGND VGND VPWR VPWR sky130_fd_sc_hd__decap_3
XFILLER_7_272 VGND VGND VPWR VPWR sky130_fd_sc_hd__decap_3
X_4451_ _4451_/A _4451_/B VGND VGND VPWR VPWR _4765_/B sky130_fd_sc_hd__nor2_2
X_3402_ _3385_/Y _3401_/X _4307_/A2 VGND VGND VPWR VPWR _3421_/C sky130_fd_sc_hd__a21oi_4
X_7170_ _7360_/CLK _7170_/D _6450_/Y VGND VGND VPWR VPWR _7170_/Q sky130_fd_sc_hd__dfrtp_2
X_4382_ _4950_/A _4967_/B VGND VGND VPWR VPWR _4383_/C sky130_fd_sc_hd__nor2_2
XFILLER_98_533 VGND VGND VPWR VPWR sky130_fd_sc_hd__fill_1
XFILLER_112_321 VGND VGND VPWR VPWR sky130_fd_sc_hd__fill_1
XFILLER_98_544 VGND VGND VPWR VPWR sky130_fd_sc_hd__decap_3
XFILLER_98_577 VGND VGND VPWR VPWR sky130_fd_sc_hd__decap_3
XFILLER_86_728 VGND VGND VPWR VPWR sky130_fd_sc_hd__decap_3
XFILLER_112_365 VGND VGND VPWR VPWR sky130_fd_sc_hd__decap_3
XFILLER_105_18 VGND VGND VPWR VPWR sky130_fd_sc_hd__decap_3
XPHY_EDGE_ROW_7_Right_7 VGND VGND VPWR VPWR sky130_fd_sc_hd__decap_3
XFILLER_85_216 VGND VGND VPWR VPWR sky130_fd_sc_hd__decap_3
XFILLER_39_611 VGND VGND VPWR VPWR sky130_fd_sc_hd__decap_3
XFILLER_100_527 VGND VGND VPWR VPWR sky130_fd_sc_hd__decap_3
XFILLER_112_387 VGND VGND VPWR VPWR sky130_fd_sc_hd__decap_3
X_5003_ _5003_/A _5003_/B VGND VGND VPWR VPWR _5003_/X sky130_fd_sc_hd__or2_2
XFILLER_85_238 VGND VGND VPWR VPWR sky130_fd_sc_hd__decap_3
XFILLER_78_290 VGND VGND VPWR VPWR sky130_fd_sc_hd__decap_3
XFILLER_66_430 VGND VGND VPWR VPWR sky130_fd_sc_hd__fill_2
XFILLER_39_644 VGND VGND VPWR VPWR sky130_fd_sc_hd__decap_3
XFILLER_66_441 VGND VGND VPWR VPWR sky130_fd_sc_hd__fill_1
XFILLER_39_688 VGND VGND VPWR VPWR sky130_fd_sc_hd__decap_3
XFILLER_54_625 VGND VGND VPWR VPWR sky130_fd_sc_hd__decap_3
XFILLER_93_293 VGND VGND VPWR VPWR sky130_fd_sc_hd__fill_1
X_6954_ _6960_/CLK _6954_/D VGND VGND VPWR VPWR _6954_/Q sky130_fd_sc_hd__dfxtp_2
XFILLER_54_669 VGND VGND VPWR VPWR sky130_fd_sc_hd__decap_3
XFILLER_121_39 VGND VGND VPWR VPWR sky130_fd_sc_hd__decap_3
X_6885_ _7405_/CLK _6885_/D VGND VGND VPWR VPWR _6885_/Q sky130_fd_sc_hd__dfxtp_2
XFILLER_14_26 VGND VGND VPWR VPWR sky130_fd_sc_hd__fill_2
XTAP_TAPCELL_ROW_62_1069 VGND VPWR sky130_fd_sc_hd__tapvpwrvgnd_1
XPHY_EDGE_ROW_101_Left_225 VGND VGND VPWR VPWR sky130_fd_sc_hd__decap_3
XFILLER_10_728 VGND VGND VPWR VPWR sky130_fd_sc_hd__decap_3
XTAP_TAPCELL_ROW_118_1803 VGND VPWR sky130_fd_sc_hd__tapvpwrvgnd_1
X_4718_ _4718_/A0 _4716_/X _4837_/S VGND VGND VPWR VPWR _7278_/D sky130_fd_sc_hd__mux2_4
XFILLER_108_616 VGND VGND VPWR VPWR sky130_fd_sc_hd__decap_3
X_4649_ _4649_/A _4649_/B _4425_/C VGND VGND VPWR VPWR _4652_/A sky130_fd_sc_hd__nor3b_2
XFILLER_107_137 VGND VGND VPWR VPWR sky130_fd_sc_hd__decap_3
XFILLER_123_608 VGND VGND VPWR VPWR sky130_fd_sc_hd__decap_3
Xhold740 _6920_/Q VGND VGND VPWR VPWR _6920_/D sky130_fd_sc_hd__dlygate4sd3_1
XFILLER_116_660 VGND VGND VPWR VPWR sky130_fd_sc_hd__decap_3
Xhold751 _6880_/Q VGND VGND VPWR VPWR _6880_/D sky130_fd_sc_hd__dlygate4sd3_1
X_7368_ _7368_/CLK _7368_/D _6648_/Y VGND VGND VPWR VPWR _7368_/Q sky130_fd_sc_hd__dfrtp_2
XFILLER_89_511 VGND VGND VPWR VPWR sky130_fd_sc_hd__fill_2
Xhold762 _6803_/Q VGND VGND VPWR VPWR _6803_/D sky130_fd_sc_hd__dlygate4sd3_1
Xhold773 _6775_/Q VGND VGND VPWR VPWR _6775_/D sky130_fd_sc_hd__dlygate4sd3_1
XFILLER_116_693 VGND VGND VPWR VPWR sky130_fd_sc_hd__decap_3
X_6319_ _6674_/A VGND VGND VPWR VPWR _6319_/Y sky130_fd_sc_hd__inv_2
Xhold784 _6774_/Q VGND VGND VPWR VPWR _6774_/D sky130_fd_sc_hd__dlygate4sd3_1
XFILLER_89_544 VGND VGND VPWR VPWR sky130_fd_sc_hd__decap_3
XFILLER_103_321 VGND VGND VPWR VPWR sky130_fd_sc_hd__decap_3
Xhold795 _6809_/Q VGND VGND VPWR VPWR _6809_/D sky130_fd_sc_hd__dlygate4sd3_1
X_7299_ _7374_/CLK _7299_/D _6579_/Y VGND VGND VPWR VPWR _7299_/Q sky130_fd_sc_hd__dfrtp_2
XFILLER_77_706 VGND VGND VPWR VPWR sky130_fd_sc_hd__decap_3
XFILLER_103_343 VGND VGND VPWR VPWR sky130_fd_sc_hd__decap_3
XPHY_EDGE_ROW_110_Left_234 VGND VGND VPWR VPWR sky130_fd_sc_hd__decap_3
XFILLER_89_588 VGND VGND VPWR VPWR sky130_fd_sc_hd__decap_3
XFILLER_103_365 VGND VGND VPWR VPWR sky130_fd_sc_hd__decap_3
XFILLER_76_216 VGND VGND VPWR VPWR sky130_fd_sc_hd__decap_3
XFILLER_76_249 VGND VGND VPWR VPWR sky130_fd_sc_hd__decap_3
XFILLER_69_290 VGND VGND VPWR VPWR sky130_fd_sc_hd__decap_3
XFILLER_57_452 VGND VGND VPWR VPWR sky130_fd_sc_hd__fill_1
XFILLER_91_219 VGND VGND VPWR VPWR sky130_fd_sc_hd__decap_3
XFILLER_84_293 VGND VGND VPWR VPWR sky130_fd_sc_hd__decap_3
XFILLER_45_647 VGND VGND VPWR VPWR sky130_fd_sc_hd__decap_3
XFILLER_29_198 VGND VGND VPWR VPWR sky130_fd_sc_hd__decap_3
XFILLER_17_349 VGND VGND VPWR VPWR sky130_fd_sc_hd__decap_3
XFILLER_55_99 VGND VGND VPWR VPWR sky130_fd_sc_hd__decap_3
XFILLER_72_488 VGND VGND VPWR VPWR sky130_fd_sc_hd__fill_1
XFILLER_60_628 VGND VGND VPWR VPWR sky130_fd_sc_hd__decap_3
XTAP_TAPCELL_ROW_43_826 VGND VPWR sky130_fd_sc_hd__tapvpwrvgnd_1
XFILLER_25_371 VGND VGND VPWR VPWR sky130_fd_sc_hd__decap_3
XFILLER_53_691 VGND VGND VPWR VPWR sky130_fd_sc_hd__decap_3
XFILLER_13_522 VGND VGND VPWR VPWR sky130_fd_sc_hd__fill_2
XFILLER_71_21 VGND VGND VPWR VPWR sky130_fd_sc_hd__decap_3
XFILLER_71_54 VGND VGND VPWR VPWR sky130_fd_sc_hd__fill_2
XFILLER_40_363 VGND VGND VPWR VPWR sky130_fd_sc_hd__fill_1
XFILLER_13_588 VGND VGND VPWR VPWR sky130_fd_sc_hd__decap_3
XTAP_TAPCELL_ROW_23_561 VGND VPWR sky130_fd_sc_hd__tapvpwrvgnd_1
XFILLER_40_374 VGND VGND VPWR VPWR sky130_fd_sc_hd__decap_3
XTAP_TAPCELL_ROW_23_572 VGND VPWR sky130_fd_sc_hd__tapvpwrvgnd_1
XFILLER_9_559 VGND VGND VPWR VPWR sky130_fd_sc_hd__fill_1
XFILLER_5_721 VGND VGND VPWR VPWR sky130_fd_sc_hd__decap_3
XFILLER_5_732 VGND VGND VPWR VPWR sky130_fd_sc_hd__decap_3
XFILLER_4_242 VGND VGND VPWR VPWR sky130_fd_sc_hd__decap_3
XFILLER_114_619 VGND VGND VPWR VPWR sky130_fd_sc_hd__decap_3
XFILLER_4_253 VGND VGND VPWR VPWR sky130_fd_sc_hd__decap_3
XFILLER_107_671 VGND VGND VPWR VPWR sky130_fd_sc_hd__fill_1
XFILLER_107_682 VGND VGND VPWR VPWR sky130_fd_sc_hd__decap_3
XFILLER_4_275 VGND VGND VPWR VPWR sky130_fd_sc_hd__decap_3
XFILLER_106_181 VGND VGND VPWR VPWR sky130_fd_sc_hd__decap_3
XFILLER_106_192 VGND VGND VPWR VPWR sky130_fd_sc_hd__decap_3
XFILLER_122_663 VGND VGND VPWR VPWR sky130_fd_sc_hd__decap_3
XFILLER_68_728 VGND VGND VPWR VPWR sky130_fd_sc_hd__decap_3
XFILLER_122_696 VGND VGND VPWR VPWR sky130_fd_sc_hd__decap_3
XFILLER_95_536 VGND VGND VPWR VPWR sky130_fd_sc_hd__fill_1
XFILLER_83_709 VGND VGND VPWR VPWR sky130_fd_sc_hd__decap_3
XFILLER_48_452 VGND VGND VPWR VPWR sky130_fd_sc_hd__decap_3
XFILLER_63_400 VGND VGND VPWR VPWR sky130_fd_sc_hd__decap_3
XFILLER_36_625 VGND VGND VPWR VPWR sky130_fd_sc_hd__decap_3
XFILLER_63_422 VGND VGND VPWR VPWR sky130_fd_sc_hd__decap_3
XFILLER_48_496 VGND VGND VPWR VPWR sky130_fd_sc_hd__fill_1
XFILLER_35_113 VGND VGND VPWR VPWR sky130_fd_sc_hd__decap_3
Xplace400 _4534_/S VGND VGND VPWR VPWR _4520_/S sky130_fd_sc_hd__buf_2
Xplace411 _4278_/B1 VGND VGND VPWR VPWR _4346_/B1 sky130_fd_sc_hd__buf_2
XFILLER_36_669 VGND VGND VPWR VPWR sky130_fd_sc_hd__decap_3
Xplace422 _3989_/S VGND VGND VPWR VPWR _3975_/S sky130_fd_sc_hd__buf_2
XFILLER_63_455 VGND VGND VPWR VPWR sky130_fd_sc_hd__decap_3
Xplace433 _4459_/C1 VGND VGND VPWR VPWR _4430_/B1 sky130_fd_sc_hd__buf_2
XFILLER_51_617 VGND VGND VPWR VPWR sky130_fd_sc_hd__decap_3
XFILLER_23_308 VGND VGND VPWR VPWR sky130_fd_sc_hd__decap_3
Xplace444 _5647_/A VGND VGND VPWR VPWR _5587_/B sky130_fd_sc_hd__buf_2
Xplace455 _6981_/Q VGND VGND VPWR VPWR _5135_/A1 sky130_fd_sc_hd__buf_2
XFILLER_63_488 VGND VGND VPWR VPWR sky130_fd_sc_hd__decap_3
XFILLER_90_296 VGND VGND VPWR VPWR sky130_fd_sc_hd__fill_2
XFILLER_16_382 VGND VGND VPWR VPWR sky130_fd_sc_hd__decap_3
X_6670_ _6672_/A VGND VGND VPWR VPWR _6670_/Y sky130_fd_sc_hd__inv_2
X_3882_ _6974_/Q _3889_/A2 _3890_/B1 _6969_/Q _3881_/X VGND VGND VPWR VPWR _3882_/X
+ sky130_fd_sc_hd__a221o_2
XFILLER_31_352 VGND VGND VPWR VPWR sky130_fd_sc_hd__decap_3
X_5621_ _5621_/A VGND VGND VPWR VPWR _5622_/A sky130_fd_sc_hd__inv_2
XFILLER_31_374 VGND VGND VPWR VPWR sky130_fd_sc_hd__decap_3
XFILLER_31_396 VGND VGND VPWR VPWR sky130_fd_sc_hd__decap_3
X_4503_ _4503_/A0 _7296_/Q _4505_/S VGND VGND VPWR VPWR _7328_/D sky130_fd_sc_hd__mux2_2
XFILLER_8_581 VGND VGND VPWR VPWR sky130_fd_sc_hd__decap_3
XFILLER_8_592 VGND VGND VPWR VPWR sky130_fd_sc_hd__decap_3
XFILLER_117_435 VGND VGND VPWR VPWR sky130_fd_sc_hd__decap_3
X_4434_ _7111_/Q _4434_/A2 _4434_/B1 _7143_/Q _4433_/X VGND VGND VPWR VPWR _4434_/X
+ sky130_fd_sc_hd__a221o_2
X_7222_ _7313_/CLK _7222_/D _6502_/Y VGND VGND VPWR VPWR _7222_/Q sky130_fd_sc_hd__dfrtp_2
XFILLER_117_479 VGND VGND VPWR VPWR sky130_fd_sc_hd__decap_3
XTAP_TAPCELL_ROW_113_1733 VGND VPWR sky130_fd_sc_hd__tapvpwrvgnd_1
XFILLER_116_17 VGND VGND VPWR VPWR sky130_fd_sc_hd__decap_3
X_7153_ _7313_/CLK _7153_/D _6433_/Y VGND VGND VPWR VPWR _7153_/Q sky130_fd_sc_hd__dfrtp_2
X_4365_ _4365_/A _4365_/B _4365_/C VGND VGND VPWR VPWR _4365_/X sky130_fd_sc_hd__and3_2
XFILLER_98_341 VGND VGND VPWR VPWR sky130_fd_sc_hd__fill_1
XFILLER_113_641 VGND VGND VPWR VPWR sky130_fd_sc_hd__decap_3
XFILLER_59_706 VGND VGND VPWR VPWR sky130_fd_sc_hd__decap_3
X_3316_ _6980_/Q _6983_/Q VGND VGND VPWR VPWR _3332_/B sky130_fd_sc_hd__nor2b_2
XFILLER_98_363 VGND VGND VPWR VPWR sky130_fd_sc_hd__fill_1
X_7084_ _7403_/CLK _7084_/D _6364_/Y VGND VGND VPWR VPWR _7084_/Q sky130_fd_sc_hd__dfrtp_2
XFILLER_113_685 VGND VGND VPWR VPWR sky130_fd_sc_hd__decap_3
X_4296_ _4292_/A wire560/X _4295_/X VGND VGND VPWR VPWR _4297_/B sky130_fd_sc_hd__a21oi_2
XFILLER_112_162 VGND VGND VPWR VPWR sky130_fd_sc_hd__decap_3
XFILLER_58_249 VGND VGND VPWR VPWR sky130_fd_sc_hd__decap_3
XFILLER_100_346 VGND VGND VPWR VPWR sky130_fd_sc_hd__fill_2
XFILLER_100_368 VGND VGND VPWR VPWR sky130_fd_sc_hd__decap_3
XFILLER_27_614 VGND VGND VPWR VPWR sky130_fd_sc_hd__fill_2
XFILLER_26_102 VGND VGND VPWR VPWR sky130_fd_sc_hd__decap_3
XFILLER_94_580 VGND VGND VPWR VPWR sky130_fd_sc_hd__decap_3
XFILLER_66_271 VGND VGND VPWR VPWR sky130_fd_sc_hd__fill_1
XFILLER_82_731 VGND VGND VPWR VPWR sky130_fd_sc_hd__decap_3
XFILLER_27_647 VGND VGND VPWR VPWR sky130_fd_sc_hd__decap_3
XFILLER_54_433 VGND VGND VPWR VPWR sky130_fd_sc_hd__decap_3
XTAP_TAPCELL_ROW_1_278 VGND VPWR sky130_fd_sc_hd__tapvpwrvgnd_1
XFILLER_81_252 VGND VGND VPWR VPWR sky130_fd_sc_hd__decap_3
XFILLER_54_477 VGND VGND VPWR VPWR sky130_fd_sc_hd__fill_1
XFILLER_42_628 VGND VGND VPWR VPWR sky130_fd_sc_hd__decap_3
XFILLER_25_36 VGND VGND VPWR VPWR sky130_fd_sc_hd__decap_3
X_6937_ _7403_/CLK _6937_/D VGND VGND VPWR VPWR _6937_/Q sky130_fd_sc_hd__dfxtp_2
XFILLER_35_691 VGND VGND VPWR VPWR sky130_fd_sc_hd__decap_3
X_6868_ _7378_/CLK _6868_/D VGND VGND VPWR VPWR _6868_/Q sky130_fd_sc_hd__dfxtp_2
XFILLER_50_672 VGND VGND VPWR VPWR sky130_fd_sc_hd__decap_3
XFILLER_22_374 VGND VGND VPWR VPWR sky130_fd_sc_hd__fill_2
X_6799_ _7405_/CLK _6799_/D VGND VGND VPWR VPWR _6799_/Q sky130_fd_sc_hd__dfxtp_2
XFILLER_10_536 VGND VGND VPWR VPWR sky130_fd_sc_hd__decap_3
XTAP_TAPCELL_ROW_20_531 VGND VPWR sky130_fd_sc_hd__tapvpwrvgnd_1
XFILLER_41_46 VGND VGND VPWR VPWR sky130_fd_sc_hd__fill_2
XFILLER_41_57 VGND VGND VPWR VPWR sky130_fd_sc_hd__fill_1
XFILLER_10_569 VGND VGND VPWR VPWR sky130_fd_sc_hd__decap_3
XFILLER_108_402 VGND VGND VPWR VPWR sky130_fd_sc_hd__decap_3
XFILLER_108_424 VGND VGND VPWR VPWR sky130_fd_sc_hd__decap_3
XTAP_TAPCELL_ROW_75_1238 VGND VPWR sky130_fd_sc_hd__tapvpwrvgnd_1
XFILLER_123_416 VGND VGND VPWR VPWR sky130_fd_sc_hd__decap_3
XFILLER_2_713 VGND VGND VPWR VPWR sky130_fd_sc_hd__decap_3
XFILLER_123_427 VGND VGND VPWR VPWR sky130_fd_sc_hd__fill_2
XFILLER_1_212 VGND VGND VPWR VPWR sky130_fd_sc_hd__decap_3
XFILLER_123_449 VGND VGND VPWR VPWR sky130_fd_sc_hd__decap_3
Xhold581 _6896_/Q VGND VGND VPWR VPWR _6896_/D sky130_fd_sc_hd__dlygate4sd3_1
XFILLER_1_234 VGND VGND VPWR VPWR sky130_fd_sc_hd__decap_3
XTAP_TAPCELL_ROW_9_378 VGND VPWR sky130_fd_sc_hd__tapvpwrvgnd_1
Xhold592 _6744_/Q VGND VGND VPWR VPWR _6744_/D sky130_fd_sc_hd__dlygate4sd3_1
XTAP_TAPCELL_ROW_9_389 VGND VPWR sky130_fd_sc_hd__tapvpwrvgnd_1
XFILLER_104_663 VGND VGND VPWR VPWR sky130_fd_sc_hd__decap_3
XFILLER_89_363 VGND VGND VPWR VPWR sky130_fd_sc_hd__fill_1
XFILLER_77_503 VGND VGND VPWR VPWR sky130_fd_sc_hd__fill_1
XFILLER_77_514 VGND VGND VPWR VPWR sky130_fd_sc_hd__fill_2
XFILLER_89_385 VGND VGND VPWR VPWR sky130_fd_sc_hd__fill_2
XFILLER_2_18 VGND VGND VPWR VPWR sky130_fd_sc_hd__decap_3
XFILLER_103_162 VGND VGND VPWR VPWR sky130_fd_sc_hd__decap_3
XFILLER_2_29 VGND VGND VPWR VPWR sky130_fd_sc_hd__decap_3
XFILLER_104_696 VGND VGND VPWR VPWR sky130_fd_sc_hd__decap_3
XFILLER_106_61 VGND VGND VPWR VPWR sky130_fd_sc_hd__fill_2
XFILLER_103_184 VGND VGND VPWR VPWR sky130_fd_sc_hd__decap_3
XFILLER_66_21 VGND VGND VPWR VPWR sky130_fd_sc_hd__decap_3
XFILLER_66_32 VGND VGND VPWR VPWR sky130_fd_sc_hd__decap_3
XFILLER_65_709 VGND VGND VPWR VPWR sky130_fd_sc_hd__decap_3
XFILLER_18_625 VGND VGND VPWR VPWR sky130_fd_sc_hd__decap_3
XFILLER_85_591 VGND VGND VPWR VPWR sky130_fd_sc_hd__decap_3
XFILLER_17_113 VGND VGND VPWR VPWR sky130_fd_sc_hd__decap_3
XTAP_TAPCELL_ROW_28_631 VGND VPWR sky130_fd_sc_hd__tapvpwrvgnd_1
XFILLER_72_230 VGND VGND VPWR VPWR sky130_fd_sc_hd__decap_3
XFILLER_18_669 VGND VGND VPWR VPWR sky130_fd_sc_hd__decap_3
XFILLER_122_71 VGND VGND VPWR VPWR sky130_fd_sc_hd__decap_3
XFILLER_72_263 VGND VGND VPWR VPWR sky130_fd_sc_hd__decap_3
XFILLER_33_617 VGND VGND VPWR VPWR sky130_fd_sc_hd__decap_3
XTAP_TAPCELL_ROW_86_1389 VGND VPWR sky130_fd_sc_hd__tapvpwrvgnd_1
XTAP_TAPCELL_ROW_56_995 VGND VPWR sky130_fd_sc_hd__tapvpwrvgnd_1
XFILLER_72_285 VGND VGND VPWR VPWR sky130_fd_sc_hd__decap_3
XFILLER_82_64 VGND VGND VPWR VPWR sky130_fd_sc_hd__decap_3
XFILLER_60_469 VGND VGND VPWR VPWR sky130_fd_sc_hd__decap_3
XFILLER_13_330 VGND VGND VPWR VPWR sky130_fd_sc_hd__decap_3
XFILLER_82_97 VGND VGND VPWR VPWR sky130_fd_sc_hd__decap_3
XFILLER_41_650 VGND VGND VPWR VPWR sky130_fd_sc_hd__decap_3
XFILLER_15_80 VGND VGND VPWR VPWR sky130_fd_sc_hd__decap_3
XFILLER_13_374 VGND VGND VPWR VPWR sky130_fd_sc_hd__decap_3
XFILLER_41_694 VGND VGND VPWR VPWR sky130_fd_sc_hd__decap_3
XFILLER_13_396 VGND VGND VPWR VPWR sky130_fd_sc_hd__decap_3
XFILLER_40_193 VGND VGND VPWR VPWR sky130_fd_sc_hd__decap_3
XFILLER_9_378 VGND VGND VPWR VPWR sky130_fd_sc_hd__decap_3
XFILLER_5_540 VGND VGND VPWR VPWR sky130_fd_sc_hd__decap_3
XFILLER_31_90 VGND VGND VPWR VPWR sky130_fd_sc_hd__decap_3
XFILLER_5_573 VGND VGND VPWR VPWR sky130_fd_sc_hd__decap_3
XFILLER_114_449 VGND VGND VPWR VPWR sky130_fd_sc_hd__decap_3
X_4150_ _7234_/Q _4414_/A2 _4108_/B _7362_/Q VGND VGND VPWR VPWR _4150_/X sky130_fd_sc_hd__a22o_2
XFILLER_122_471 VGND VGND VPWR VPWR sky130_fd_sc_hd__decap_3
XFILLER_110_622 VGND VGND VPWR VPWR sky130_fd_sc_hd__decap_3
XFILLER_95_322 VGND VGND VPWR VPWR sky130_fd_sc_hd__decap_3
X_4081_ _4451_/A _4451_/B VGND VGND VPWR VPWR _4081_/X sky130_fd_sc_hd__or2b_2
XFILLER_110_666 VGND VGND VPWR VPWR sky130_fd_sc_hd__decap_3
XFILLER_55_208 VGND VGND VPWR VPWR sky130_fd_sc_hd__decap_3
XFILLER_110_699 VGND VGND VPWR VPWR sky130_fd_sc_hd__fill_1
XFILLER_64_731 VGND VGND VPWR VPWR sky130_fd_sc_hd__decap_3
XFILLER_36_433 VGND VGND VPWR VPWR sky130_fd_sc_hd__fill_1
XFILLER_36_455 VGND VGND VPWR VPWR sky130_fd_sc_hd__decap_3
XFILLER_91_561 VGND VGND VPWR VPWR sky130_fd_sc_hd__decap_3
XFILLER_36_477 VGND VGND VPWR VPWR sky130_fd_sc_hd__decap_3
XFILLER_24_628 VGND VGND VPWR VPWR sky130_fd_sc_hd__decap_3
XFILLER_51_414 VGND VGND VPWR VPWR sky130_fd_sc_hd__decap_3
XFILLER_23_105 VGND VGND VPWR VPWR sky130_fd_sc_hd__decap_3
XFILLER_91_594 VGND VGND VPWR VPWR sky130_fd_sc_hd__decap_3
X_4983_ _4983_/A _4983_/B _4983_/C VGND VGND VPWR VPWR _4983_/X sky130_fd_sc_hd__and3_2
XFILLER_17_691 VGND VGND VPWR VPWR sky130_fd_sc_hd__decap_3
Xplace274 _3665_/X VGND VGND VPWR VPWR _3892_/B1 sky130_fd_sc_hd__buf_2
XFILLER_51_458 VGND VGND VPWR VPWR sky130_fd_sc_hd__fill_1
XFILLER_23_149 VGND VGND VPWR VPWR sky130_fd_sc_hd__decap_3
X_6722_ _7215_/CLK _6722_/D VGND VGND VPWR VPWR _6722_/Q sky130_fd_sc_hd__dfxtp_2
Xplace285 _3906_/A2 VGND VGND VPWR VPWR _3926_/A2 sky130_fd_sc_hd__buf_2
Xplace296 _3656_/Y VGND VGND VPWR VPWR _3890_/B1 sky130_fd_sc_hd__buf_2
XFILLER_32_672 VGND VGND VPWR VPWR sky130_fd_sc_hd__decap_3
XFILLER_31_160 VGND VGND VPWR VPWR sky130_fd_sc_hd__decap_3
X_6653_ _6653_/A VGND VGND VPWR VPWR _6653_/Y sky130_fd_sc_hd__inv_2
X_3796_ _6726_/Q _3888_/A2 _3891_/A2 _6976_/Q _3795_/X VGND VGND VPWR VPWR _3796_/X
+ sky130_fd_sc_hd__a221o_2
X_6584_ _6618_/A VGND VGND VPWR VPWR _6584_/Y sky130_fd_sc_hd__inv_2
XFILLER_118_722 VGND VGND VPWR VPWR sky130_fd_sc_hd__decap_3
XFILLER_11_49 VGND VGND VPWR VPWR sky130_fd_sc_hd__decap_3
XFILLER_117_243 VGND VGND VPWR VPWR sky130_fd_sc_hd__decap_3
XFILLER_117_265 VGND VGND VPWR VPWR sky130_fd_sc_hd__decap_3
XFILLER_117_287 VGND VGND VPWR VPWR sky130_fd_sc_hd__decap_3
XFILLER_105_438 VGND VGND VPWR VPWR sky130_fd_sc_hd__fill_1
X_4417_ _7304_/Q _4914_/S _4434_/A2 _7112_/Q _4416_/X VGND VGND VPWR VPWR _4417_/X
+ sky130_fd_sc_hd__a221o_2
X_7205_ _7368_/CLK _7205_/D _6485_/Y VGND VGND VPWR VPWR _7205_/Q sky130_fd_sc_hd__dfrtp_2
XFILLER_99_650 VGND VGND VPWR VPWR sky130_fd_sc_hd__decap_3
XFILLER_101_600 VGND VGND VPWR VPWR sky130_fd_sc_hd__decap_3
X_4348_ _7161_/Q _4348_/A2 _4348_/B1 _7129_/Q _4347_/X VGND VGND VPWR VPWR _4348_/X
+ sky130_fd_sc_hd__a221o_2
X_7136_ _7360_/CLK _7136_/D _6416_/Y VGND VGND VPWR VPWR _7136_/Q sky130_fd_sc_hd__dfrtp_2
XFILLER_98_160 VGND VGND VPWR VPWR sky130_fd_sc_hd__decap_3
XFILLER_99_694 VGND VGND VPWR VPWR sky130_fd_sc_hd__decap_3
XTAP_TAPCELL_ROW_6_348 VGND VPWR sky130_fd_sc_hd__tapvpwrvgnd_1
XFILLER_98_182 VGND VGND VPWR VPWR sky130_fd_sc_hd__decap_3
XFILLER_101_644 VGND VGND VPWR VPWR sky130_fd_sc_hd__decap_3
X_7067_ _7387_/CLK _7067_/D _6347_/Y VGND VGND VPWR VPWR _7067_/Q sky130_fd_sc_hd__dfrtp_2
XFILLER_47_709 VGND VGND VPWR VPWR sky130_fd_sc_hd__decap_3
XTAP_TAPCELL_ROW_70_1179 VGND VPWR sky130_fd_sc_hd__tapvpwrvgnd_1
X_4279_ _7318_/Q _3987_/S _5229_/C _7126_/Q VGND VGND VPWR VPWR _4279_/X sky130_fd_sc_hd__a22o_2
XFILLER_46_219 VGND VGND VPWR VPWR sky130_fd_sc_hd__decap_3
XFILLER_101_688 VGND VGND VPWR VPWR sky130_fd_sc_hd__decap_3
XFILLER_100_165 VGND VGND VPWR VPWR sky130_fd_sc_hd__decap_3
XFILLER_86_388 VGND VGND VPWR VPWR sky130_fd_sc_hd__fill_2
XFILLER_27_411 VGND VGND VPWR VPWR sky130_fd_sc_hd__fill_1
XFILLER_27_433 VGND VGND VPWR VPWR sky130_fd_sc_hd__decap_3
XFILLER_15_606 VGND VGND VPWR VPWR sky130_fd_sc_hd__decap_3
XFILLER_70_701 VGND VGND VPWR VPWR sky130_fd_sc_hd__decap_3
XFILLER_15_617 VGND VGND VPWR VPWR sky130_fd_sc_hd__decap_3
XFILLER_82_583 VGND VGND VPWR VPWR sky130_fd_sc_hd__decap_3
XFILLER_42_414 VGND VGND VPWR VPWR sky130_fd_sc_hd__decap_3
XFILLER_27_488 VGND VGND VPWR VPWR sky130_fd_sc_hd__decap_3
XFILLER_70_734 VGND VGND VPWR VPWR sky130_fd_sc_hd__fill_1
XFILLER_14_138 VGND VGND VPWR VPWR sky130_fd_sc_hd__fill_2
XTAP_TAPCELL_ROW_53_954 VGND VPWR sky130_fd_sc_hd__tapvpwrvgnd_1
XFILLER_23_650 VGND VGND VPWR VPWR sky130_fd_sc_hd__decap_3
XFILLER_23_694 VGND VGND VPWR VPWR sky130_fd_sc_hd__decap_3
XFILLER_109_700 VGND VGND VPWR VPWR sky130_fd_sc_hd__decap_3
XFILLER_6_315 VGND VGND VPWR VPWR sky130_fd_sc_hd__decap_3
XFILLER_2_510 VGND VGND VPWR VPWR sky130_fd_sc_hd__decap_3
XFILLER_108_298 VGND VGND VPWR VPWR sky130_fd_sc_hd__decap_3
XFILLER_97_609 VGND VGND VPWR VPWR sky130_fd_sc_hd__decap_3
XFILLER_2_554 VGND VGND VPWR VPWR sky130_fd_sc_hd__decap_3
XFILLER_117_60 VGND VGND VPWR VPWR sky130_fd_sc_hd__decap_3
XFILLER_77_31 VGND VGND VPWR VPWR sky130_fd_sc_hd__decap_3
XFILLER_77_311 VGND VGND VPWR VPWR sky130_fd_sc_hd__decap_3
XFILLER_2_587 VGND VGND VPWR VPWR sky130_fd_sc_hd__fill_1
XFILLER_117_93 VGND VGND VPWR VPWR sky130_fd_sc_hd__decap_3
XFILLER_104_471 VGND VGND VPWR VPWR sky130_fd_sc_hd__decap_3
XFILLER_2_598 VGND VGND VPWR VPWR sky130_fd_sc_hd__decap_3
XFILLER_89_193 VGND VGND VPWR VPWR sky130_fd_sc_hd__decap_3
XTAP_TAPCELL_ROW_88_1407 VGND VPWR sky130_fd_sc_hd__tapvpwrvgnd_1
XFILLER_65_517 VGND VGND VPWR VPWR sky130_fd_sc_hd__decap_3
XFILLER_18_400 VGND VGND VPWR VPWR sky130_fd_sc_hd__decap_3
XFILLER_92_325 VGND VGND VPWR VPWR sky130_fd_sc_hd__decap_3
XFILLER_77_399 VGND VGND VPWR VPWR sky130_fd_sc_hd__decap_3
XFILLER_65_539 VGND VGND VPWR VPWR sky130_fd_sc_hd__decap_3
XFILLER_46_731 VGND VGND VPWR VPWR sky130_fd_sc_hd__decap_3
XFILLER_18_433 VGND VGND VPWR VPWR sky130_fd_sc_hd__decap_3
XFILLER_92_358 VGND VGND VPWR VPWR sky130_fd_sc_hd__decap_3
XFILLER_61_712 VGND VGND VPWR VPWR sky130_fd_sc_hd__decap_3
XFILLER_18_477 VGND VGND VPWR VPWR sky130_fd_sc_hd__decap_3
XFILLER_45_274 VGND VGND VPWR VPWR sky130_fd_sc_hd__decap_3
XFILLER_18_499 VGND VGND VPWR VPWR sky130_fd_sc_hd__decap_3
XFILLER_45_296 VGND VGND VPWR VPWR sky130_fd_sc_hd__decap_3
XFILLER_33_447 VGND VGND VPWR VPWR sky130_fd_sc_hd__fill_1
XFILLER_33_458 VGND VGND VPWR VPWR sky130_fd_sc_hd__decap_3
XFILLER_60_277 VGND VGND VPWR VPWR sky130_fd_sc_hd__decap_3
XFILLER_14_672 VGND VGND VPWR VPWR sky130_fd_sc_hd__decap_3
XFILLER_41_480 VGND VGND VPWR VPWR sky130_fd_sc_hd__decap_3
XFILLER_41_491 VGND VGND VPWR VPWR sky130_fd_sc_hd__decap_3
XFILLER_13_182 VGND VGND VPWR VPWR sky130_fd_sc_hd__decap_3
XFILLER_119_508 VGND VGND VPWR VPWR sky130_fd_sc_hd__decap_3
XFILLER_9_142 VGND VGND VPWR VPWR sky130_fd_sc_hd__decap_3
X_3650_ _3991_/B VGND VGND VPWR VPWR _3665_/A sky130_fd_sc_hd__inv_2
XTAP_TAPCELL_ROW_99_1558 VGND VPWR sky130_fd_sc_hd__tapvpwrvgnd_1
X_3581_ _7156_/Q _3409_/X _3579_/X _3580_/X VGND VGND VPWR VPWR _3583_/B sky130_fd_sc_hd__a211o_2
XFILLER_115_703 VGND VGND VPWR VPWR sky130_fd_sc_hd__decap_3
XFILLER_5_370 VGND VGND VPWR VPWR sky130_fd_sc_hd__fill_1
XFILLER_114_224 VGND VGND VPWR VPWR sky130_fd_sc_hd__decap_3
X_5251_ _5251_/A0 _4899_/X _5278_/S VGND VGND VPWR VPWR _7204_/D sky130_fd_sc_hd__mux2_2
XTAP_TAPCELL_ROW_110_1703 VGND VPWR sky130_fd_sc_hd__tapvpwrvgnd_1
X_4202_ _4202_/A VGND VGND VPWR VPWR _4203_/C sky130_fd_sc_hd__inv_2
XFILLER_87_119 VGND VGND VPWR VPWR sky130_fd_sc_hd__decap_3
X_5182_ _7237_/Q _5207_/B VGND VGND VPWR VPWR _7237_/D sky130_fd_sc_hd__and2_2
XFILLER_96_631 VGND VGND VPWR VPWR sky130_fd_sc_hd__decap_3
XFILLER_68_322 VGND VGND VPWR VPWR sky130_fd_sc_hd__fill_2
X_4133_ _7363_/Q _4108_/B _4436_/B1 _7171_/Q VGND VGND VPWR VPWR _4133_/X sky130_fd_sc_hd__a22o_2
XTAP_TAPCELL_ROW_3_307 VGND VPWR sky130_fd_sc_hd__tapvpwrvgnd_1
XFILLER_29_709 VGND VGND VPWR VPWR sky130_fd_sc_hd__decap_3
XFILLER_95_141 VGND VGND VPWR VPWR sky130_fd_sc_hd__decap_3
XFILLER_96_675 VGND VGND VPWR VPWR sky130_fd_sc_hd__decap_3
XFILLER_110_474 VGND VGND VPWR VPWR sky130_fd_sc_hd__fill_2
X_4064_ _7372_/Q _4394_/B _4914_/S _7308_/Q _4063_/X VGND VGND VPWR VPWR _4064_/X
+ sky130_fd_sc_hd__a221o_2
XFILLER_113_18 VGND VGND VPWR VPWR sky130_fd_sc_hd__decap_3
XFILLER_95_185 VGND VGND VPWR VPWR sky130_fd_sc_hd__decap_3
XFILLER_52_701 VGND VGND VPWR VPWR sky130_fd_sc_hd__decap_3
XTAP_TAPCELL_ROW_108_1665 VGND VPWR sky130_fd_sc_hd__tapvpwrvgnd_1
XTAP_TAPCELL_ROW_108_1676 VGND VPWR sky130_fd_sc_hd__tapvpwrvgnd_1
XFILLER_52_734 VGND VGND VPWR VPWR sky130_fd_sc_hd__fill_1
XFILLER_51_211 VGND VGND VPWR VPWR sky130_fd_sc_hd__fill_2
XFILLER_51_222 VGND VGND VPWR VPWR sky130_fd_sc_hd__fill_2
XTAP_TAPCELL_ROW_121_1843 VGND VPWR sky130_fd_sc_hd__tapvpwrvgnd_1
XTAP_TAPCELL_ROW_50_913 VGND VPWR sky130_fd_sc_hd__tapvpwrvgnd_1
X_6705_ _6942_/CLK _6705_/D VGND VGND VPWR VPWR _6705_/Q sky130_fd_sc_hd__dfxtp_2
X_3917_ _6689_/Q _3917_/A2 _3925_/B1 _6867_/Q VGND VGND VPWR VPWR _3917_/X sky130_fd_sc_hd__a22o_2
XFILLER_20_631 VGND VGND VPWR VPWR sky130_fd_sc_hd__decap_3
X_4897_ _4896_/A _4896_/B _4896_/Y _5015_/A VGND VGND VPWR VPWR _4897_/X sky130_fd_sc_hd__o211a_2
XFILLER_22_26 VGND VGND VPWR VPWR sky130_fd_sc_hd__fill_2
X_6636_ _6637_/A VGND VGND VPWR VPWR _6636_/Y sky130_fd_sc_hd__inv_2
X_3848_ _6907_/Q _3886_/A2 _5660_/B _6851_/Q VGND VGND VPWR VPWR _3848_/X sky130_fd_sc_hd__a22o_2
XFILLER_20_675 VGND VGND VPWR VPWR sky130_fd_sc_hd__decap_3
X_3779_ _6794_/Q _3926_/B1 _5660_/B _6704_/Q _3778_/X VGND VGND VPWR VPWR _3779_/X
+ sky130_fd_sc_hd__a221o_2
X_6567_ _6568_/A VGND VGND VPWR VPWR _6567_/Y sky130_fd_sc_hd__inv_2
XFILLER_118_563 VGND VGND VPWR VPWR sky130_fd_sc_hd__decap_3
XFILLER_106_725 VGND VGND VPWR VPWR sky130_fd_sc_hd__decap_3
X_6498_ _6594_/A VGND VGND VPWR VPWR _6498_/Y sky130_fd_sc_hd__inv_2
XTAP_TAPCELL_ROW_72_1208 VGND VPWR sky130_fd_sc_hd__tapvpwrvgnd_1
XFILLER_79_609 VGND VGND VPWR VPWR sky130_fd_sc_hd__decap_3
XFILLER_121_706 VGND VGND VPWR VPWR sky130_fd_sc_hd__decap_3
Xoutput461 _5650_/Y VGND VGND VPWR VPWR alu_result_out[0] sky130_fd_sc_hd__clkdlybuf4s25_1
Xoutput472 _5659_/B VGND VGND VPWR VPWR alu_result_out[1] sky130_fd_sc_hd__clkdlybuf4s25_1
XFILLER_120_205 VGND VGND VPWR VPWR sky130_fd_sc_hd__decap_3
Xoutput483 _3634_/Y VGND VGND VPWR VPWR alu_result_out[2] sky130_fd_sc_hd__clkdlybuf4s25_1
Xoutput494 _5647_/Y VGND VGND VPWR VPWR instruction_out[11] sky130_fd_sc_hd__clkdlybuf4s25_1
XFILLER_87_620 VGND VGND VPWR VPWR sky130_fd_sc_hd__decap_3
XFILLER_59_322 VGND VGND VPWR VPWR sky130_fd_sc_hd__decap_3
XFILLER_59_333 VGND VGND VPWR VPWR sky130_fd_sc_hd__decap_3
XFILLER_120_249 VGND VGND VPWR VPWR sky130_fd_sc_hd__decap_3
X_7119_ _7279_/CLK _7119_/D _6399_/Y VGND VGND VPWR VPWR _7119_/Q sky130_fd_sc_hd__dfrtp_2
XFILLER_87_653 VGND VGND VPWR VPWR sky130_fd_sc_hd__decap_3
XFILLER_113_290 VGND VGND VPWR VPWR sky130_fd_sc_hd__decap_3
XFILLER_86_141 VGND VGND VPWR VPWR sky130_fd_sc_hd__decap_3
XFILLER_101_452 VGND VGND VPWR VPWR sky130_fd_sc_hd__decap_3
XFILLER_59_377 VGND VGND VPWR VPWR sky130_fd_sc_hd__fill_1
XFILLER_86_163 VGND VGND VPWR VPWR sky130_fd_sc_hd__decap_3
XFILLER_87_697 VGND VGND VPWR VPWR sky130_fd_sc_hd__decap_3
XFILLER_59_399 VGND VGND VPWR VPWR sky130_fd_sc_hd__decap_3
XFILLER_101_485 VGND VGND VPWR VPWR sky130_fd_sc_hd__decap_3
XFILLER_28_731 VGND VGND VPWR VPWR sky130_fd_sc_hd__decap_3
XFILLER_55_561 VGND VGND VPWR VPWR sky130_fd_sc_hd__decap_3
XFILLER_43_712 VGND VGND VPWR VPWR sky130_fd_sc_hd__decap_3
XFILLER_42_200 VGND VGND VPWR VPWR sky130_fd_sc_hd__decap_3
XFILLER_15_425 VGND VGND VPWR VPWR sky130_fd_sc_hd__fill_2
XFILLER_15_436 VGND VGND VPWR VPWR sky130_fd_sc_hd__decap_3
XFILLER_103_84 VGND VGND VPWR VPWR sky130_fd_sc_hd__decap_3
XFILLER_70_531 VGND VGND VPWR VPWR sky130_fd_sc_hd__fill_1
XTAP_TAPCELL_ROW_83_1348 VGND VPWR sky130_fd_sc_hd__tapvpwrvgnd_1
XFILLER_42_233 VGND VGND VPWR VPWR sky130_fd_sc_hd__fill_1
XFILLER_30_406 VGND VGND VPWR VPWR sky130_fd_sc_hd__decap_3
XFILLER_42_266 VGND VGND VPWR VPWR sky130_fd_sc_hd__decap_3
XFILLER_42_288 VGND VGND VPWR VPWR sky130_fd_sc_hd__decap_3
XFILLER_11_620 VGND VGND VPWR VPWR sky130_fd_sc_hd__decap_3
XFILLER_11_653 VGND VGND VPWR VPWR sky130_fd_sc_hd__decap_3
XFILLER_7_635 VGND VGND VPWR VPWR sky130_fd_sc_hd__decap_3
XFILLER_11_697 VGND VGND VPWR VPWR sky130_fd_sc_hd__decap_3
XFILLER_7_668 VGND VGND VPWR VPWR sky130_fd_sc_hd__decap_3
XFILLER_109_552 VGND VGND VPWR VPWR sky130_fd_sc_hd__decap_3
XFILLER_7_679 VGND VGND VPWR VPWR sky130_fd_sc_hd__decap_3
XFILLER_6_167 VGND VGND VPWR VPWR sky130_fd_sc_hd__decap_3
XFILLER_12_81 VGND VGND VPWR VPWR sky130_fd_sc_hd__decap_3
XFILLER_109_585 VGND VGND VPWR VPWR sky130_fd_sc_hd__decap_3
XTAP_TAPCELL_ROW_94_1488 VGND VPWR sky130_fd_sc_hd__tapvpwrvgnd_1
XFILLER_88_63 VGND VGND VPWR VPWR sky130_fd_sc_hd__decap_3
XFILLER_112_728 VGND VGND VPWR VPWR sky130_fd_sc_hd__decap_3
XFILLER_97_428 VGND VGND VPWR VPWR sky130_fd_sc_hd__decap_3
XFILLER_88_85 VGND VGND VPWR VPWR sky130_fd_sc_hd__decap_3
XFILLER_69_119 VGND VGND VPWR VPWR sky130_fd_sc_hd__fill_2
XFILLER_78_631 VGND VGND VPWR VPWR sky130_fd_sc_hd__decap_3
XFILLER_111_238 VGND VGND VPWR VPWR sky130_fd_sc_hd__decap_3
XFILLER_104_290 VGND VGND VPWR VPWR sky130_fd_sc_hd__decap_3
XFILLER_78_675 VGND VGND VPWR VPWR sky130_fd_sc_hd__decap_3
XFILLER_77_141 VGND VGND VPWR VPWR sky130_fd_sc_hd__decap_3
XFILLER_93_612 VGND VGND VPWR VPWR sky130_fd_sc_hd__decap_3
XFILLER_93_623 VGND VGND VPWR VPWR sky130_fd_sc_hd__decap_3
XFILLER_65_314 VGND VGND VPWR VPWR sky130_fd_sc_hd__decap_3
XFILLER_38_528 VGND VGND VPWR VPWR sky130_fd_sc_hd__decap_3
XFILLER_77_196 VGND VGND VPWR VPWR sky130_fd_sc_hd__decap_3
XFILLER_93_656 VGND VGND VPWR VPWR sky130_fd_sc_hd__decap_3
XFILLER_34_701 VGND VGND VPWR VPWR sky130_fd_sc_hd__decap_3
XTAP_TAPCELL_ROW_36_729 VGND VPWR sky130_fd_sc_hd__tapvpwrvgnd_1
XFILLER_92_177 VGND VGND VPWR VPWR sky130_fd_sc_hd__decap_3
XFILLER_80_339 VGND VGND VPWR VPWR sky130_fd_sc_hd__decap_3
XFILLER_34_734 VGND VGND VPWR VPWR sky130_fd_sc_hd__fill_1
XFILLER_33_200 VGND VGND VPWR VPWR sky130_fd_sc_hd__decap_3
XFILLER_61_520 VGND VGND VPWR VPWR sky130_fd_sc_hd__decap_3
X_4820_ _5156_/S _5634_/B VGND VGND VPWR VPWR _5010_/A sky130_fd_sc_hd__nand2_2
XFILLER_21_406 VGND VGND VPWR VPWR sky130_fd_sc_hd__decap_3
XFILLER_61_586 VGND VGND VPWR VPWR sky130_fd_sc_hd__decap_3
XFILLER_33_277 VGND VGND VPWR VPWR sky130_fd_sc_hd__decap_3
XTAP_TAPCELL_ROW_16_475 VGND VPWR sky130_fd_sc_hd__tapvpwrvgnd_1
XFILLER_33_288 VGND VGND VPWR VPWR sky130_fd_sc_hd__decap_3
X_4751_ _4751_/A _4751_/B VGND VGND VPWR VPWR _4751_/Y sky130_fd_sc_hd__nand2_2
X_3702_ hold965/X _4832_/A _3701_/X VGND VGND VPWR VPWR _7401_/D sky130_fd_sc_hd__o21a_2
X_4682_ _4928_/B _4682_/B _4960_/B VGND VGND VPWR VPWR _4943_/A sky130_fd_sc_hd__and3b_2
XFILLER_119_349 VGND VGND VPWR VPWR sky130_fd_sc_hd__decap_3
X_3633_ _3636_/A _5114_/A _5033_/B2 _3630_/A VGND VGND VPWR VPWR _3633_/Y sky130_fd_sc_hd__a22oi_2
X_6421_ _6650_/A VGND VGND VPWR VPWR _6421_/Y sky130_fd_sc_hd__inv_2
XFILLER_115_500 VGND VGND VPWR VPWR sky130_fd_sc_hd__decap_3
X_3564_ _5118_/A _5362_/C VGND VGND VPWR VPWR _3564_/X sky130_fd_sc_hd__and2_2
X_6352_ _6674_/A VGND VGND VPWR VPWR _6352_/Y sky130_fd_sc_hd__inv_2
XFILLER_115_511 VGND VGND VPWR VPWR sky130_fd_sc_hd__decap_3
XFILLER_108_29 VGND VGND VPWR VPWR sky130_fd_sc_hd__decap_3
XFILLER_6_690 VGND VGND VPWR VPWR sky130_fd_sc_hd__decap_3
XFILLER_115_544 VGND VGND VPWR VPWR sky130_fd_sc_hd__decap_3
X_6283_ _6462_/A VGND VGND VPWR VPWR _6283_/Y sky130_fd_sc_hd__inv_2
X_3495_ _7028_/Q _3488_/B _3494_/X VGND VGND VPWR VPWR _3495_/X sky130_fd_sc_hd__a21o_2
XFILLER_103_706 VGND VGND VPWR VPWR sky130_fd_sc_hd__decap_3
XFILLER_115_588 VGND VGND VPWR VPWR sky130_fd_sc_hd__decap_3
X_5234_ _5234_/A0 _4734_/X _5258_/S VGND VGND VPWR VPWR _7213_/D sky130_fd_sc_hd__mux2_2
XFILLER_69_620 VGND VGND VPWR VPWR sky130_fd_sc_hd__decap_3
XFILLER_69_653 VGND VGND VPWR VPWR sky130_fd_sc_hd__decap_3
X_5165_ _5165_/A _5200_/B VGND VGND VPWR VPWR _7245_/D sky130_fd_sc_hd__and2_2
XFILLER_96_450 VGND VGND VPWR VPWR sky130_fd_sc_hd__decap_3
XFILLER_68_141 VGND VGND VPWR VPWR sky130_fd_sc_hd__decap_3
XFILLER_84_601 VGND VGND VPWR VPWR sky130_fd_sc_hd__decap_3
X_4116_ _7076_/Q _4265_/B VGND VGND VPWR VPWR _4117_/C sky130_fd_sc_hd__or2_2
XFILLER_69_697 VGND VGND VPWR VPWR sky130_fd_sc_hd__decap_3
XFILLER_56_314 VGND VGND VPWR VPWR sky130_fd_sc_hd__decap_3
XFILLER_29_528 VGND VGND VPWR VPWR sky130_fd_sc_hd__decap_3
XFILLER_96_483 VGND VGND VPWR VPWR sky130_fd_sc_hd__decap_3
XFILLER_83_100 VGND VGND VPWR VPWR sky130_fd_sc_hd__decap_3
XFILLER_84_634 VGND VGND VPWR VPWR sky130_fd_sc_hd__decap_3
XFILLER_110_271 VGND VGND VPWR VPWR sky130_fd_sc_hd__decap_3
XFILLER_84_645 VGND VGND VPWR VPWR sky130_fd_sc_hd__decap_3
XFILLER_83_122 VGND VGND VPWR VPWR sky130_fd_sc_hd__decap_3
XFILLER_56_358 VGND VGND VPWR VPWR sky130_fd_sc_hd__fill_2
X_4047_ _7245_/Q _4433_/B _4431_/A2 _7027_/Q _4046_/X VGND VGND VPWR VPWR _4047_/X
+ sky130_fd_sc_hd__a221o_2
XFILLER_84_678 VGND VGND VPWR VPWR sky130_fd_sc_hd__decap_3
XFILLER_83_144 VGND VGND VPWR VPWR sky130_fd_sc_hd__decap_3
XFILLER_71_317 VGND VGND VPWR VPWR sky130_fd_sc_hd__decap_3
XFILLER_25_712 VGND VGND VPWR VPWR sky130_fd_sc_hd__decap_3
XTAP_TAPCELL_ROW_69_1170 VGND VPWR sky130_fd_sc_hd__tapvpwrvgnd_1
XFILLER_24_200 VGND VGND VPWR VPWR sky130_fd_sc_hd__fill_2
XFILLER_37_594 VGND VGND VPWR VPWR sky130_fd_sc_hd__decap_3
XFILLER_52_531 VGND VGND VPWR VPWR sky130_fd_sc_hd__fill_1
XFILLER_64_391 VGND VGND VPWR VPWR sky130_fd_sc_hd__fill_1
XFILLER_40_704 VGND VGND VPWR VPWR sky130_fd_sc_hd__decap_3
XFILLER_24_277 VGND VGND VPWR VPWR sky130_fd_sc_hd__decap_3
XFILLER_12_417 VGND VGND VPWR VPWR sky130_fd_sc_hd__decap_3
X_4949_ _4967_/A _4967_/B VGND VGND VPWR VPWR _4949_/Y sky130_fd_sc_hd__nand2_2
X_6619_ _6619_/A VGND VGND VPWR VPWR _6619_/Y sky130_fd_sc_hd__inv_2
XFILLER_4_616 VGND VGND VPWR VPWR sky130_fd_sc_hd__decap_3
XFILLER_106_533 VGND VGND VPWR VPWR sky130_fd_sc_hd__decap_3
XFILLER_106_566 VGND VGND VPWR VPWR sky130_fd_sc_hd__decap_3
XFILLER_79_417 VGND VGND VPWR VPWR sky130_fd_sc_hd__decap_3
XFILLER_121_503 VGND VGND VPWR VPWR sky130_fd_sc_hd__fill_1
XFILLER_121_514 VGND VGND VPWR VPWR sky130_fd_sc_hd__decap_3
XFILLER_79_439 VGND VGND VPWR VPWR sky130_fd_sc_hd__decap_3
XFILLER_58_33 VGND VGND VPWR VPWR sky130_fd_sc_hd__decap_3
XFILLER_121_547 VGND VGND VPWR VPWR sky130_fd_sc_hd__decap_3
XFILLER_75_612 VGND VGND VPWR VPWR sky130_fd_sc_hd__decap_3
XFILLER_58_99 VGND VGND VPWR VPWR sky130_fd_sc_hd__fill_2
XFILLER_75_623 VGND VGND VPWR VPWR sky130_fd_sc_hd__decap_3
XFILLER_47_325 VGND VGND VPWR VPWR sky130_fd_sc_hd__decap_3
XFILLER_59_196 VGND VGND VPWR VPWR sky130_fd_sc_hd__decap_3
XFILLER_114_50 VGND VGND VPWR VPWR sky130_fd_sc_hd__decap_3
XFILLER_75_656 VGND VGND VPWR VPWR sky130_fd_sc_hd__decap_3
XFILLER_74_21 VGND VGND VPWR VPWR sky130_fd_sc_hd__decap_3
XFILLER_74_144 VGND VGND VPWR VPWR sky130_fd_sc_hd__decap_3
XFILLER_47_358 VGND VGND VPWR VPWR sky130_fd_sc_hd__fill_1
XFILLER_90_604 VGND VGND VPWR VPWR sky130_fd_sc_hd__decap_3
XFILLER_74_32 VGND VGND VPWR VPWR sky130_fd_sc_hd__fill_2
XFILLER_28_550 VGND VGND VPWR VPWR sky130_fd_sc_hd__decap_3
XFILLER_114_83 VGND VGND VPWR VPWR sky130_fd_sc_hd__fill_1
XFILLER_16_701 VGND VGND VPWR VPWR sky130_fd_sc_hd__decap_3
XFILLER_74_177 VGND VGND VPWR VPWR sky130_fd_sc_hd__decap_3
XFILLER_90_637 VGND VGND VPWR VPWR sky130_fd_sc_hd__decap_3
XFILLER_28_583 VGND VGND VPWR VPWR sky130_fd_sc_hd__decap_3
XFILLER_90_648 VGND VGND VPWR VPWR sky130_fd_sc_hd__decap_3
XFILLER_16_734 VGND VGND VPWR VPWR sky130_fd_sc_hd__fill_1
XFILLER_43_564 VGND VGND VPWR VPWR sky130_fd_sc_hd__decap_3
XFILLER_31_715 VGND VGND VPWR VPWR sky130_fd_sc_hd__decap_3
XFILLER_70_394 VGND VGND VPWR VPWR sky130_fd_sc_hd__decap_3
XTAP_TAPCELL_ROW_13_434 VGND VPWR sky130_fd_sc_hd__tapvpwrvgnd_1
XFILLER_7_421 VGND VGND VPWR VPWR sky130_fd_sc_hd__decap_3
XFILLER_11_472 VGND VGND VPWR VPWR sky130_fd_sc_hd__decap_3
XTAP_TAPCELL_ROW_41_798 VGND VPWR sky130_fd_sc_hd__tapvpwrvgnd_1
XTAP_TAPCELL_ROW_96_1517 VGND VPWR sky130_fd_sc_hd__tapvpwrvgnd_1
XFILLER_7_465 VGND VGND VPWR VPWR sky130_fd_sc_hd__decap_3
XFILLER_99_51 VGND VGND VPWR VPWR sky130_fd_sc_hd__decap_3
XFILLER_109_371 VGND VGND VPWR VPWR sky130_fd_sc_hd__decap_3
XFILLER_109_393 VGND VGND VPWR VPWR sky130_fd_sc_hd__decap_3
XFILLER_99_84 VGND VGND VPWR VPWR sky130_fd_sc_hd__decap_3
XFILLER_98_704 VGND VGND VPWR VPWR sky130_fd_sc_hd__decap_3
XFILLER_97_203 VGND VGND VPWR VPWR sky130_fd_sc_hd__decap_3
XFILLER_3_671 VGND VGND VPWR VPWR sky130_fd_sc_hd__fill_1
XFILLER_112_525 VGND VGND VPWR VPWR sky130_fd_sc_hd__decap_3
XFILLER_97_225 VGND VGND VPWR VPWR sky130_fd_sc_hd__fill_1
XFILLER_3_682 VGND VGND VPWR VPWR sky130_fd_sc_hd__decap_3
XFILLER_112_536 VGND VGND VPWR VPWR sky130_fd_sc_hd__decap_3
XFILLER_2_192 VGND VGND VPWR VPWR sky130_fd_sc_hd__decap_3
XFILLER_112_569 VGND VGND VPWR VPWR sky130_fd_sc_hd__decap_3
XFILLER_66_612 VGND VGND VPWR VPWR sky130_fd_sc_hd__decap_3
XFILLER_78_483 VGND VGND VPWR VPWR sky130_fd_sc_hd__decap_3
XFILLER_66_645 VGND VGND VPWR VPWR sky130_fd_sc_hd__decap_3
XFILLER_17_3 VGND VGND VPWR VPWR sky130_fd_sc_hd__fill_2
XFILLER_66_678 VGND VGND VPWR VPWR sky130_fd_sc_hd__decap_3
X_6970_ clkload6/A _6970_/D VGND VGND VPWR VPWR _6970_/Q sky130_fd_sc_hd__dfxtp_2
XFILLER_81_615 VGND VGND VPWR VPWR sky130_fd_sc_hd__fill_1
XFILLER_19_561 VGND VGND VPWR VPWR sky130_fd_sc_hd__decap_3
XFILLER_93_486 VGND VGND VPWR VPWR sky130_fd_sc_hd__decap_3
XFILLER_81_626 VGND VGND VPWR VPWR sky130_fd_sc_hd__decap_3
XFILLER_80_103 VGND VGND VPWR VPWR sky130_fd_sc_hd__decap_3
XFILLER_53_317 VGND VGND VPWR VPWR sky130_fd_sc_hd__decap_3
XTAP_TAPCELL_ROW_49_898 VGND VPWR sky130_fd_sc_hd__tapvpwrvgnd_1
XFILLER_81_659 VGND VGND VPWR VPWR sky130_fd_sc_hd__decap_3
XFILLER_34_520 VGND VGND VPWR VPWR sky130_fd_sc_hd__decap_3
XFILLER_19_594 VGND VGND VPWR VPWR sky130_fd_sc_hd__decap_3
XTAP_TAPCELL_ROW_105_1635 VGND VPWR sky130_fd_sc_hd__tapvpwrvgnd_1
XFILLER_80_147 VGND VGND VPWR VPWR sky130_fd_sc_hd__fill_1
XFILLER_22_704 VGND VGND VPWR VPWR sky130_fd_sc_hd__decap_3
X_4803_ _7003_/Q _4802_/X _4677_/B _5667_/A VGND VGND VPWR VPWR _4804_/B sky130_fd_sc_hd__o211ai_2
XFILLER_21_225 VGND VGND VPWR VPWR sky130_fd_sc_hd__decap_3
XFILLER_21_258 VGND VGND VPWR VPWR sky130_fd_sc_hd__decap_3
X_4734_ _4726_/X _4729_/Y _7007_/D _5040_/S VGND VGND VPWR VPWR _4734_/X sky130_fd_sc_hd__o22a_2
XFILLER_119_102 VGND VGND VPWR VPWR sky130_fd_sc_hd__decap_3
XFILLER_119_113 VGND VGND VPWR VPWR sky130_fd_sc_hd__decap_3
X_4665_ _7005_/Q _4690_/B VGND VGND VPWR VPWR _4665_/X sky130_fd_sc_hd__or2_2
XFILLER_119_39 VGND VGND VPWR VPWR sky130_fd_sc_hd__decap_3
XFILLER_119_179 VGND VGND VPWR VPWR sky130_fd_sc_hd__decap_3
X_6404_ _6596_/A VGND VGND VPWR VPWR _6404_/Y sky130_fd_sc_hd__inv_2
X_3616_ _4614_/C _3616_/B VGND VGND VPWR VPWR _3616_/Y sky130_fd_sc_hd__nand2_2
Xhold900 _7110_/Q VGND VGND VPWR VPWR _7110_/D sky130_fd_sc_hd__dlygate4sd3_1
Xhold911 _6697_/Q VGND VGND VPWR VPWR hold911/X sky130_fd_sc_hd__dlygate4sd3_1
X_7384_ _7386_/CLK _7384_/D _6664_/Y VGND VGND VPWR VPWR _7384_/Q sky130_fd_sc_hd__dfrtp_2
Xhold922 _6695_/Q VGND VGND VPWR VPWR hold922/X sky130_fd_sc_hd__dlygate4sd3_1
Xhold933 _7395_/Q VGND VGND VPWR VPWR hold933/X sky130_fd_sc_hd__dlygate4sd3_1
XTAP_TAPCELL_ROW_116_1775 VGND VPWR sky130_fd_sc_hd__tapvpwrvgnd_1
X_6335_ _6591_/A VGND VGND VPWR VPWR _6335_/Y sky130_fd_sc_hd__inv_2
Xhold944 _7406_/Q VGND VGND VPWR VPWR hold944/X sky130_fd_sc_hd__dlygate4sd3_1
X_3547_ _3547_/A _3547_/B VGND VGND VPWR VPWR _3547_/Y sky130_fd_sc_hd__nand2_2
Xhold955 _7030_/Q VGND VGND VPWR VPWR _5595_/A sky130_fd_sc_hd__dlygate4sd3_1
XFILLER_89_715 VGND VGND VPWR VPWR sky130_fd_sc_hd__decap_3
Xhold966 _7054_/Q VGND VGND VPWR VPWR hold966/X sky130_fd_sc_hd__dlygate4sd3_1
XFILLER_103_503 VGND VGND VPWR VPWR sky130_fd_sc_hd__fill_1
Xhold977 _7375_/Q VGND VGND VPWR VPWR hold977/X sky130_fd_sc_hd__dlygate4sd3_1
XFILLER_88_203 VGND VGND VPWR VPWR sky130_fd_sc_hd__decap_3
Xhold988 _7258_/Q VGND VGND VPWR VPWR hold988/X sky130_fd_sc_hd__dlygate4sd3_1
XFILLER_115_385 VGND VGND VPWR VPWR sky130_fd_sc_hd__fill_2
X_3478_ _7216_/Q _4353_/A2 _4534_/S _7029_/Q _3477_/X VGND VGND VPWR VPWR _3478_/X
+ sky130_fd_sc_hd__a221o_2
X_6266_ _6674_/A VGND VGND VPWR VPWR _6266_/Y sky130_fd_sc_hd__inv_2
Xhold999 _7191_/Q VGND VGND VPWR VPWR hold999/X sky130_fd_sc_hd__dlygate4sd3_1
XFILLER_115_396 VGND VGND VPWR VPWR sky130_fd_sc_hd__fill_1
XFILLER_103_547 VGND VGND VPWR VPWR sky130_fd_sc_hd__decap_3
XFILLER_88_247 VGND VGND VPWR VPWR sky130_fd_sc_hd__decap_3
X_5217_ _5217_/A _5223_/B VGND VGND VPWR VPWR _7220_/D sky130_fd_sc_hd__and2_2
XFILLER_69_461 VGND VGND VPWR VPWR sky130_fd_sc_hd__decap_3
XFILLER_57_623 VGND VGND VPWR VPWR sky130_fd_sc_hd__decap_3
X_5148_ _5144_/A _5071_/A _3521_/Y _3540_/X VGND VGND VPWR VPWR _5148_/X sky130_fd_sc_hd__a211o_2
XFILLER_56_111 VGND VGND VPWR VPWR sky130_fd_sc_hd__fill_2
XFILLER_111_591 VGND VGND VPWR VPWR sky130_fd_sc_hd__decap_3
XFILLER_57_656 VGND VGND VPWR VPWR sky130_fd_sc_hd__decap_3
XFILLER_56_133 VGND VGND VPWR VPWR sky130_fd_sc_hd__decap_3
XFILLER_56_144 VGND VGND VPWR VPWR sky130_fd_sc_hd__decap_3
X_5079_ _5156_/S _6987_/D _5078_/X VGND VGND VPWR VPWR _5079_/X sky130_fd_sc_hd__o21a_2
XFILLER_72_604 VGND VGND VPWR VPWR sky130_fd_sc_hd__decap_3
XFILLER_84_475 VGND VGND VPWR VPWR sky130_fd_sc_hd__fill_1
XFILLER_44_306 VGND VGND VPWR VPWR sky130_fd_sc_hd__fill_2
XFILLER_72_637 VGND VGND VPWR VPWR sky130_fd_sc_hd__decap_3
XFILLER_72_648 VGND VGND VPWR VPWR sky130_fd_sc_hd__decap_3
XFILLER_71_169 VGND VGND VPWR VPWR sky130_fd_sc_hd__decap_3
XTAP_TAPCELL_ROW_80_1307 VGND VPWR sky130_fd_sc_hd__tapvpwrvgnd_1
XFILLER_44_57 VGND VGND VPWR VPWR sky130_fd_sc_hd__fill_2
XFILLER_40_501 VGND VGND VPWR VPWR sky130_fd_sc_hd__decap_3
XFILLER_13_715 VGND VGND VPWR VPWR sky130_fd_sc_hd__decap_3
XFILLER_80_681 VGND VGND VPWR VPWR sky130_fd_sc_hd__decap_3
XFILLER_25_597 VGND VGND VPWR VPWR sky130_fd_sc_hd__decap_3
XFILLER_12_225 VGND VGND VPWR VPWR sky130_fd_sc_hd__decap_3
XFILLER_40_545 VGND VGND VPWR VPWR sky130_fd_sc_hd__decap_3
XFILLER_40_556 VGND VGND VPWR VPWR sky130_fd_sc_hd__decap_3
XFILLER_8_207 VGND VGND VPWR VPWR sky130_fd_sc_hd__decap_3
XFILLER_60_23 VGND VGND VPWR VPWR sky130_fd_sc_hd__decap_3
XFILLER_40_589 VGND VGND VPWR VPWR sky130_fd_sc_hd__decap_3
XFILLER_100_85 VGND VGND VPWR VPWR sky130_fd_sc_hd__decap_3
XFILLER_121_3 VGND VGND VPWR VPWR sky130_fd_sc_hd__decap_3
XFILLER_20_280 VGND VGND VPWR VPWR sky130_fd_sc_hd__decap_3
XFILLER_4_413 VGND VGND VPWR VPWR sky130_fd_sc_hd__decap_3
XFILLER_4_424 VGND VGND VPWR VPWR sky130_fd_sc_hd__fill_1
XFILLER_119_691 VGND VGND VPWR VPWR sky130_fd_sc_hd__decap_3
XFILLER_4_446 VGND VGND VPWR VPWR sky130_fd_sc_hd__decap_3
XFILLER_69_21 VGND VGND VPWR VPWR sky130_fd_sc_hd__decap_3
XFILLER_69_54 VGND VGND VPWR VPWR sky130_fd_sc_hd__fill_2
XTAP_TAPCELL_ROW_91_1447 VGND VPWR sky130_fd_sc_hd__tapvpwrvgnd_1
XFILLER_106_396 VGND VGND VPWR VPWR sky130_fd_sc_hd__fill_1
XFILLER_79_247 VGND VGND VPWR VPWR sky130_fd_sc_hd__decap_3
XFILLER_95_718 VGND VGND VPWR VPWR sky130_fd_sc_hd__decap_3
XFILLER_0_641 VGND VGND VPWR VPWR sky130_fd_sc_hd__decap_3
XFILLER_95_729 VGND VGND VPWR VPWR sky130_fd_sc_hd__decap_3
XFILLER_94_206 VGND VGND VPWR VPWR sky130_fd_sc_hd__decap_3
XFILLER_48_612 VGND VGND VPWR VPWR sky130_fd_sc_hd__decap_3
XFILLER_94_239 VGND VGND VPWR VPWR sky130_fd_sc_hd__fill_2
XFILLER_0_696 VGND VGND VPWR VPWR sky130_fd_sc_hd__decap_3
XFILLER_85_53 VGND VGND VPWR VPWR sky130_fd_sc_hd__decap_3
XFILLER_48_645 VGND VGND VPWR VPWR sky130_fd_sc_hd__decap_3
XFILLER_63_604 VGND VGND VPWR VPWR sky130_fd_sc_hd__decap_3
XFILLER_48_678 VGND VGND VPWR VPWR sky130_fd_sc_hd__decap_3
XFILLER_85_97 VGND VGND VPWR VPWR sky130_fd_sc_hd__decap_3
XFILLER_47_166 VGND VGND VPWR VPWR sky130_fd_sc_hd__fill_2
XTAP_TAPCELL_ROW_18_504 VGND VPWR sky130_fd_sc_hd__tapvpwrvgnd_1
XFILLER_63_626 VGND VGND VPWR VPWR sky130_fd_sc_hd__decap_3
XFILLER_35_317 VGND VGND VPWR VPWR sky130_fd_sc_hd__decap_3
XFILLER_47_188 VGND VGND VPWR VPWR sky130_fd_sc_hd__decap_3
XFILLER_18_80 VGND VGND VPWR VPWR sky130_fd_sc_hd__decap_3
XFILLER_63_659 VGND VGND VPWR VPWR sky130_fd_sc_hd__decap_3
XTAP_TAPCELL_ROW_46_868 VGND VPWR sky130_fd_sc_hd__tapvpwrvgnd_1
XFILLER_90_467 VGND VGND VPWR VPWR sky130_fd_sc_hd__decap_3
XFILLER_62_169 VGND VGND VPWR VPWR sky130_fd_sc_hd__decap_3
XFILLER_50_309 VGND VGND VPWR VPWR sky130_fd_sc_hd__decap_3
XFILLER_16_564 VGND VGND VPWR VPWR sky130_fd_sc_hd__decap_3
XFILLER_31_501 VGND VGND VPWR VPWR sky130_fd_sc_hd__decap_3
XFILLER_70_191 VGND VGND VPWR VPWR sky130_fd_sc_hd__decap_3
XFILLER_86_6 VGND VGND VPWR VPWR sky130_fd_sc_hd__decap_3
XTAP_TAPCELL_ROW_100_1565 VGND VPWR sky130_fd_sc_hd__tapvpwrvgnd_1
XFILLER_117_606 VGND VGND VPWR VPWR sky130_fd_sc_hd__decap_3
XFILLER_117_617 VGND VGND VPWR VPWR sky130_fd_sc_hd__decap_3
X_4450_ _4451_/A _4451_/B VGND VGND VPWR VPWR _4452_/A sky130_fd_sc_hd__and2_2
X_3401_ _4467_/A _3519_/B _5294_/A _3330_/Y VGND VGND VPWR VPWR _3401_/X sky130_fd_sc_hd__a31o_4
X_4381_ _4381_/A _4381_/B VGND VGND VPWR VPWR _4967_/B sky130_fd_sc_hd__nand2_2
X_3332_ _4467_/A _3332_/B VGND VGND VPWR VPWR _3341_/A sky130_fd_sc_hd__nand2_2
XFILLER_98_556 VGND VGND VPWR VPWR sky130_fd_sc_hd__decap_3
XFILLER_86_707 VGND VGND VPWR VPWR sky130_fd_sc_hd__decap_3
XFILLER_112_344 VGND VGND VPWR VPWR sky130_fd_sc_hd__decap_3
XFILLER_98_589 VGND VGND VPWR VPWR sky130_fd_sc_hd__decap_3
X_5002_ _5003_/A _5003_/B _4948_/A VGND VGND VPWR VPWR _5002_/Y sky130_fd_sc_hd__a21oi_2
XFILLER_39_623 VGND VGND VPWR VPWR sky130_fd_sc_hd__decap_3
XFILLER_112_399 VGND VGND VPWR VPWR sky130_fd_sc_hd__decap_3
XFILLER_38_111 VGND VGND VPWR VPWR sky130_fd_sc_hd__fill_2
XFILLER_39_656 VGND VGND VPWR VPWR sky130_fd_sc_hd__decap_3
XFILLER_66_453 VGND VGND VPWR VPWR sky130_fd_sc_hd__decap_3
XFILLER_54_604 VGND VGND VPWR VPWR sky130_fd_sc_hd__decap_3
XFILLER_66_475 VGND VGND VPWR VPWR sky130_fd_sc_hd__fill_1
XFILLER_38_166 VGND VGND VPWR VPWR sky130_fd_sc_hd__decap_3
XFILLER_66_486 VGND VGND VPWR VPWR sky130_fd_sc_hd__fill_1
XFILLER_53_103 VGND VGND VPWR VPWR sky130_fd_sc_hd__fill_1
XFILLER_54_637 VGND VGND VPWR VPWR sky130_fd_sc_hd__decap_3
XFILLER_54_648 VGND VGND VPWR VPWR sky130_fd_sc_hd__decap_3
XFILLER_26_339 VGND VGND VPWR VPWR sky130_fd_sc_hd__decap_3
XFILLER_121_18 VGND VGND VPWR VPWR sky130_fd_sc_hd__decap_3
X_6953_ _6965_/CLK _6953_/D VGND VGND VPWR VPWR _6953_/Q sky130_fd_sc_hd__dfxtp_2
XFILLER_19_380 VGND VGND VPWR VPWR sky130_fd_sc_hd__fill_2
XFILLER_19_391 VGND VGND VPWR VPWR sky130_fd_sc_hd__fill_1
XFILLER_53_147 VGND VGND VPWR VPWR sky130_fd_sc_hd__decap_3
XFILLER_81_478 VGND VGND VPWR VPWR sky130_fd_sc_hd__decap_3
XFILLER_41_309 VGND VGND VPWR VPWR sky130_fd_sc_hd__decap_3
X_6884_ _7401_/CLK _6884_/D VGND VGND VPWR VPWR _6884_/Q sky130_fd_sc_hd__dfxtp_2
Xclkbuf_3_5__f_clk clkbuf_0_clk/X VGND VGND VPWR VPWR clkload2/A sky130_fd_sc_hd__clkbuf_16
XFILLER_62_681 VGND VGND VPWR VPWR sky130_fd_sc_hd__decap_3
XFILLER_22_512 VGND VGND VPWR VPWR sky130_fd_sc_hd__fill_2
XFILLER_22_523 VGND VGND VPWR VPWR sky130_fd_sc_hd__fill_1
XFILLER_34_383 VGND VGND VPWR VPWR sky130_fd_sc_hd__decap_3
XFILLER_34_394 VGND VGND VPWR VPWR sky130_fd_sc_hd__decap_3
XFILLER_61_191 VGND VGND VPWR VPWR sky130_fd_sc_hd__decap_3
XFILLER_22_545 VGND VGND VPWR VPWR sky130_fd_sc_hd__decap_3
XFILLER_14_49 VGND VGND VPWR VPWR sky130_fd_sc_hd__decap_3
XFILLER_10_707 VGND VGND VPWR VPWR sky130_fd_sc_hd__decap_3
XFILLER_22_578 VGND VGND VPWR VPWR sky130_fd_sc_hd__decap_3
XFILLER_22_589 VGND VGND VPWR VPWR sky130_fd_sc_hd__decap_3
XTAP_TAPCELL_ROW_118_1804 VGND VPWR sky130_fd_sc_hd__tapvpwrvgnd_1
X_5697_ _7354_/Q hold916/X _5712_/S VGND VGND VPWR VPWR _6698_/D sky130_fd_sc_hd__mux2_2
XFILLER_108_628 VGND VGND VPWR VPWR sky130_fd_sc_hd__decap_3
XFILLER_107_116 VGND VGND VPWR VPWR sky130_fd_sc_hd__decap_3
X_4648_ _4648_/A VGND VGND VPWR VPWR _4648_/Y sky130_fd_sc_hd__inv_2
XFILLER_107_149 VGND VGND VPWR VPWR sky130_fd_sc_hd__decap_3
Xhold730 _6958_/Q VGND VGND VPWR VPWR _6958_/D sky130_fd_sc_hd__dlygate4sd3_1
Xhold741 _6978_/Q VGND VGND VPWR VPWR _6978_/D sky130_fd_sc_hd__dlygate4sd3_1
X_7367_ _7399_/CLK _7367_/D _6647_/Y VGND VGND VPWR VPWR _7367_/Q sky130_fd_sc_hd__dfrtp_2
X_4579_ _4579_/A _4595_/B VGND VGND VPWR VPWR _7291_/D sky130_fd_sc_hd__and2_2
Xhold752 _6788_/Q VGND VGND VPWR VPWR _6788_/D sky130_fd_sc_hd__dlygate4sd3_1
XFILLER_116_672 VGND VGND VPWR VPWR sky130_fd_sc_hd__decap_3
Xhold763 _6950_/Q VGND VGND VPWR VPWR _6950_/D sky130_fd_sc_hd__dlygate4sd3_1
X_6318_ _6674_/A VGND VGND VPWR VPWR _6318_/Y sky130_fd_sc_hd__inv_2
Xhold774 _6799_/Q VGND VGND VPWR VPWR _6799_/D sky130_fd_sc_hd__dlygate4sd3_1
Xhold785 _6801_/Q VGND VGND VPWR VPWR _6801_/D sky130_fd_sc_hd__dlygate4sd3_1
Xhold796 _6787_/Q VGND VGND VPWR VPWR _6787_/D sky130_fd_sc_hd__dlygate4sd3_1
X_7298_ _7365_/CLK _7298_/D _6578_/Y VGND VGND VPWR VPWR _7298_/Q sky130_fd_sc_hd__dfrtp_2
XFILLER_1_449 VGND VGND VPWR VPWR sky130_fd_sc_hd__fill_1
XFILLER_89_556 VGND VGND VPWR VPWR sky130_fd_sc_hd__decap_3
XFILLER_103_333 VGND VGND VPWR VPWR sky130_fd_sc_hd__decap_3
XFILLER_89_567 VGND VGND VPWR VPWR sky130_fd_sc_hd__decap_3
XFILLER_77_718 VGND VGND VPWR VPWR sky130_fd_sc_hd__decap_3
XFILLER_103_355 VGND VGND VPWR VPWR sky130_fd_sc_hd__decap_3
XFILLER_77_729 VGND VGND VPWR VPWR sky130_fd_sc_hd__decap_3
XFILLER_39_46 VGND VGND VPWR VPWR sky130_fd_sc_hd__fill_1
XFILLER_39_57 VGND VGND VPWR VPWR sky130_fd_sc_hd__decap_3
XFILLER_76_228 VGND VGND VPWR VPWR sky130_fd_sc_hd__decap_3
XFILLER_103_399 VGND VGND VPWR VPWR sky130_fd_sc_hd__decap_3
XFILLER_57_442 VGND VGND VPWR VPWR sky130_fd_sc_hd__decap_3
XFILLER_45_604 VGND VGND VPWR VPWR sky130_fd_sc_hd__decap_3
XFILLER_84_250 VGND VGND VPWR VPWR sky130_fd_sc_hd__fill_2
XFILLER_45_626 VGND VGND VPWR VPWR sky130_fd_sc_hd__decap_3
XFILLER_84_272 VGND VGND VPWR VPWR sky130_fd_sc_hd__fill_2
XFILLER_45_659 VGND VGND VPWR VPWR sky130_fd_sc_hd__decap_3
XFILLER_72_467 VGND VGND VPWR VPWR sky130_fd_sc_hd__decap_3
XFILLER_32_309 VGND VGND VPWR VPWR sky130_fd_sc_hd__decap_3
XTAP_TAPCELL_ROW_43_827 VGND VPWR sky130_fd_sc_hd__tapvpwrvgnd_1
XFILLER_111_51 VGND VGND VPWR VPWR sky130_fd_sc_hd__decap_3
XFILLER_25_383 VGND VGND VPWR VPWR sky130_fd_sc_hd__fill_1
XFILLER_71_33 VGND VGND VPWR VPWR sky130_fd_sc_hd__decap_3
XFILLER_13_545 VGND VGND VPWR VPWR sky130_fd_sc_hd__decap_3
XFILLER_9_505 VGND VGND VPWR VPWR sky130_fd_sc_hd__decap_3
XFILLER_40_342 VGND VGND VPWR VPWR sky130_fd_sc_hd__decap_3
XFILLER_13_567 VGND VGND VPWR VPWR sky130_fd_sc_hd__decap_3
XFILLER_9_538 VGND VGND VPWR VPWR sky130_fd_sc_hd__decap_3
XTAP_TAPCELL_ROW_23_562 VGND VPWR sky130_fd_sc_hd__tapvpwrvgnd_1
XFILLER_71_88 VGND VGND VPWR VPWR sky130_fd_sc_hd__decap_3
XFILLER_40_386 VGND VGND VPWR VPWR sky130_fd_sc_hd__decap_3
XFILLER_5_700 VGND VGND VPWR VPWR sky130_fd_sc_hd__decap_3
XFILLER_4_221 VGND VGND VPWR VPWR sky130_fd_sc_hd__fill_2
XFILLER_107_650 VGND VGND VPWR VPWR sky130_fd_sc_hd__decap_3
XFILLER_4_265 VGND VGND VPWR VPWR sky130_fd_sc_hd__decap_3
XFILLER_113_119 VGND VGND VPWR VPWR sky130_fd_sc_hd__decap_3
XFILLER_4_287 VGND VGND VPWR VPWR sky130_fd_sc_hd__decap_3
XFILLER_107_694 VGND VGND VPWR VPWR sky130_fd_sc_hd__decap_3
XFILLER_122_631 VGND VGND VPWR VPWR sky130_fd_sc_hd__decap_3
XFILLER_68_707 VGND VGND VPWR VPWR sky130_fd_sc_hd__decap_3
XFILLER_122_675 VGND VGND VPWR VPWR sky130_fd_sc_hd__decap_3
XFILLER_67_217 VGND VGND VPWR VPWR sky130_fd_sc_hd__decap_3
XFILLER_96_74 VGND VGND VPWR VPWR sky130_fd_sc_hd__decap_3
XFILLER_0_471 VGND VGND VPWR VPWR sky130_fd_sc_hd__fill_2
XFILLER_96_85 VGND VGND VPWR VPWR sky130_fd_sc_hd__fill_2
XFILLER_67_239 VGND VGND VPWR VPWR sky130_fd_sc_hd__fill_1
XFILLER_95_559 VGND VGND VPWR VPWR sky130_fd_sc_hd__fill_1
XFILLER_121_196 VGND VGND VPWR VPWR sky130_fd_sc_hd__decap_3
XFILLER_82_209 VGND VGND VPWR VPWR sky130_fd_sc_hd__decap_3
XFILLER_36_604 VGND VGND VPWR VPWR sky130_fd_sc_hd__decap_3
XFILLER_48_475 VGND VGND VPWR VPWR sky130_fd_sc_hd__fill_1
XFILLER_75_261 VGND VGND VPWR VPWR sky130_fd_sc_hd__decap_3
XFILLER_91_721 VGND VGND VPWR VPWR sky130_fd_sc_hd__decap_3
XFILLER_36_637 VGND VGND VPWR VPWR sky130_fd_sc_hd__decap_3
XFILLER_91_732 VGND VGND VPWR VPWR sky130_fd_sc_hd__decap_3
Xplace401 _4429_/A2 VGND VGND VPWR VPWR _4488_/S sky130_fd_sc_hd__buf_2
XFILLER_90_220 VGND VGND VPWR VPWR sky130_fd_sc_hd__decap_3
XFILLER_63_434 VGND VGND VPWR VPWR sky130_fd_sc_hd__decap_3
XFILLER_36_648 VGND VGND VPWR VPWR sky130_fd_sc_hd__decap_3
XFILLER_35_125 VGND VGND VPWR VPWR sky130_fd_sc_hd__fill_2
Xplace412 _3380_/Y VGND VGND VPWR VPWR _4278_/B1 sky130_fd_sc_hd__buf_2
Xplace423 _3977_/S VGND VGND VPWR VPWR _3989_/S sky130_fd_sc_hd__buf_2
XFILLER_51_607 VGND VGND VPWR VPWR sky130_fd_sc_hd__decap_3
Xplace434 _4348_/A2 VGND VGND VPWR VPWR _4459_/C1 sky130_fd_sc_hd__buf_2
XFILLER_90_253 VGND VGND VPWR VPWR sky130_fd_sc_hd__decap_3
XFILLER_63_467 VGND VGND VPWR VPWR sky130_fd_sc_hd__decap_3
Xplace445 _4414_/A2 VGND VGND VPWR VPWR _4433_/B sky130_fd_sc_hd__buf_2
XFILLER_35_169 VGND VGND VPWR VPWR sky130_fd_sc_hd__decap_3
Xplace456 _6981_/Q VGND VGND VPWR VPWR _3371_/A sky130_fd_sc_hd__buf_2
XFILLER_51_629 VGND VGND VPWR VPWR sky130_fd_sc_hd__decap_3
XFILLER_90_275 VGND VGND VPWR VPWR sky130_fd_sc_hd__decap_3
XFILLER_44_681 VGND VGND VPWR VPWR sky130_fd_sc_hd__decap_3
XFILLER_16_394 VGND VGND VPWR VPWR sky130_fd_sc_hd__decap_3
XFILLER_31_320 VGND VGND VPWR VPWR sky130_fd_sc_hd__decap_3
X_3881_ _6724_/Q _3884_/A2 _3891_/B1 _6719_/Q VGND VGND VPWR VPWR _3881_/X sky130_fd_sc_hd__a22o_2
XFILLER_8_560 VGND VGND VPWR VPWR sky130_fd_sc_hd__decap_3
X_7221_ _7313_/CLK _7221_/D _6501_/Y VGND VGND VPWR VPWR _7221_/Q sky130_fd_sc_hd__dfrtp_2
XFILLER_105_609 VGND VGND VPWR VPWR sky130_fd_sc_hd__decap_3
X_4433_ _7239_/Q _4433_/B VGND VGND VPWR VPWR _4433_/X sky130_fd_sc_hd__and2_2
XFILLER_6_83 VGND VGND VPWR VPWR sky130_fd_sc_hd__fill_1
XTAP_TAPCELL_ROW_113_1734 VGND VPWR sky130_fd_sc_hd__tapvpwrvgnd_1
X_7152_ _7345_/CLK _7152_/D _6432_/Y VGND VGND VPWR VPWR _7152_/Q sky130_fd_sc_hd__dfrtp_2
XFILLER_113_620 VGND VGND VPWR VPWR sky130_fd_sc_hd__decap_3
X_4364_ _4364_/A _4364_/B VGND VGND VPWR VPWR _4364_/Y sky130_fd_sc_hd__nor2_2
XFILLER_116_29 VGND VGND VPWR VPWR sky130_fd_sc_hd__decap_3
XFILLER_113_653 VGND VGND VPWR VPWR sky130_fd_sc_hd__decap_3
XFILLER_59_718 VGND VGND VPWR VPWR sky130_fd_sc_hd__decap_3
XFILLER_112_141 VGND VGND VPWR VPWR sky130_fd_sc_hd__fill_1
X_4295_ _3607_/B _4295_/B VGND VGND VPWR VPWR _4295_/X sky130_fd_sc_hd__and2b_2
X_7083_ _7372_/CLK _7083_/D _6363_/Y VGND VGND VPWR VPWR _7083_/Q sky130_fd_sc_hd__dfrtp_2
XFILLER_98_375 VGND VGND VPWR VPWR sky130_fd_sc_hd__decap_3
XFILLER_59_729 VGND VGND VPWR VPWR sky130_fd_sc_hd__decap_3
XFILLER_113_697 VGND VGND VPWR VPWR sky130_fd_sc_hd__decap_3
XFILLER_58_239 VGND VGND VPWR VPWR sky130_fd_sc_hd__fill_1
XFILLER_73_209 VGND VGND VPWR VPWR sky130_fd_sc_hd__decap_3
XFILLER_82_710 VGND VGND VPWR VPWR sky130_fd_sc_hd__decap_3
XFILLER_39_486 VGND VGND VPWR VPWR sky130_fd_sc_hd__decap_3
XFILLER_27_626 VGND VGND VPWR VPWR sky130_fd_sc_hd__decap_3
XFILLER_94_592 VGND VGND VPWR VPWR sky130_fd_sc_hd__decap_3
XFILLER_66_283 VGND VGND VPWR VPWR sky130_fd_sc_hd__decap_3
XFILLER_26_114 VGND VGND VPWR VPWR sky130_fd_sc_hd__decap_3
XFILLER_81_220 VGND VGND VPWR VPWR sky130_fd_sc_hd__decap_3
XFILLER_27_659 VGND VGND VPWR VPWR sky130_fd_sc_hd__decap_3
XFILLER_81_231 VGND VGND VPWR VPWR sky130_fd_sc_hd__decap_3
XFILLER_26_136 VGND VGND VPWR VPWR sky130_fd_sc_hd__decap_3
XTAP_TAPCELL_ROW_1_279 VGND VPWR sky130_fd_sc_hd__tapvpwrvgnd_1
XFILLER_42_607 VGND VGND VPWR VPWR sky130_fd_sc_hd__decap_3
XFILLER_14_309 VGND VGND VPWR VPWR sky130_fd_sc_hd__decap_3
X_6936_ clkload9/A _6936_/D VGND VGND VPWR VPWR _6936_/Q sky130_fd_sc_hd__dfxtp_2
XFILLER_81_275 VGND VGND VPWR VPWR sky130_fd_sc_hd__decap_3
XFILLER_34_180 VGND VGND VPWR VPWR sky130_fd_sc_hd__decap_3
X_6867_ _6926_/CLK _6867_/D VGND VGND VPWR VPWR _6867_/Q sky130_fd_sc_hd__dfxtp_2
XFILLER_50_640 VGND VGND VPWR VPWR sky130_fd_sc_hd__decap_3
XFILLER_22_331 VGND VGND VPWR VPWR sky130_fd_sc_hd__decap_3
XFILLER_50_651 VGND VGND VPWR VPWR sky130_fd_sc_hd__decap_3
XFILLER_22_353 VGND VGND VPWR VPWR sky130_fd_sc_hd__fill_1
XFILLER_10_504 VGND VGND VPWR VPWR sky130_fd_sc_hd__decap_3
XFILLER_50_684 VGND VGND VPWR VPWR sky130_fd_sc_hd__decap_3
X_6798_ _6942_/CLK _6798_/D VGND VGND VPWR VPWR _6798_/Q sky130_fd_sc_hd__dfxtp_2
XFILLER_10_548 VGND VGND VPWR VPWR sky130_fd_sc_hd__decap_3
XTAP_TAPCELL_ROW_20_521 VGND VPWR sky130_fd_sc_hd__tapvpwrvgnd_1
XTAP_TAPCELL_ROW_20_532 VGND VPWR sky130_fd_sc_hd__tapvpwrvgnd_1
XFILLER_41_69 VGND VGND VPWR VPWR sky130_fd_sc_hd__decap_3
XFILLER_108_414 VGND VGND VPWR VPWR sky130_fd_sc_hd__decap_3
XTAP_TAPCELL_ROW_75_1239 VGND VPWR sky130_fd_sc_hd__tapvpwrvgnd_1
XFILLER_2_725 VGND VGND VPWR VPWR sky130_fd_sc_hd__decap_3
XFILLER_116_491 VGND VGND VPWR VPWR sky130_fd_sc_hd__decap_3
XFILLER_104_631 VGND VGND VPWR VPWR sky130_fd_sc_hd__decap_3
Xhold582 _6856_/Q VGND VGND VPWR VPWR _6856_/D sky130_fd_sc_hd__dlygate4sd3_1
XTAP_TAPCELL_ROW_9_379 VGND VPWR sky130_fd_sc_hd__tapvpwrvgnd_1
Xhold593 _6732_/Q VGND VGND VPWR VPWR _6732_/D sky130_fd_sc_hd__dlygate4sd3_1
XFILLER_1_246 VGND VGND VPWR VPWR sky130_fd_sc_hd__decap_3
XFILLER_103_130 VGND VGND VPWR VPWR sky130_fd_sc_hd__decap_3
XFILLER_104_675 VGND VGND VPWR VPWR sky130_fd_sc_hd__decap_3
XFILLER_49_217 VGND VGND VPWR VPWR sky130_fd_sc_hd__decap_3
XFILLER_1_279 VGND VGND VPWR VPWR sky130_fd_sc_hd__fill_1
XFILLER_49_228 VGND VGND VPWR VPWR sky130_fd_sc_hd__decap_3
XFILLER_66_55 VGND VGND VPWR VPWR sky130_fd_sc_hd__decap_3
XFILLER_64_209 VGND VGND VPWR VPWR sky130_fd_sc_hd__decap_3
XFILLER_18_604 VGND VGND VPWR VPWR sky130_fd_sc_hd__decap_3
XFILLER_85_570 VGND VGND VPWR VPWR sky130_fd_sc_hd__decap_3
XFILLER_73_721 VGND VGND VPWR VPWR sky130_fd_sc_hd__decap_3
XFILLER_57_272 VGND VGND VPWR VPWR sky130_fd_sc_hd__decap_3
XFILLER_73_732 VGND VGND VPWR VPWR sky130_fd_sc_hd__decap_3
XFILLER_18_637 VGND VGND VPWR VPWR sky130_fd_sc_hd__decap_3
XFILLER_18_648 VGND VGND VPWR VPWR sky130_fd_sc_hd__decap_3
XFILLER_57_294 VGND VGND VPWR VPWR sky130_fd_sc_hd__decap_3
XTAP_TAPCELL_ROW_28_632 VGND VPWR sky130_fd_sc_hd__tapvpwrvgnd_1
XFILLER_45_445 VGND VGND VPWR VPWR sky130_fd_sc_hd__decap_3
XFILLER_122_50 VGND VGND VPWR VPWR sky130_fd_sc_hd__decap_3
XFILLER_72_242 VGND VGND VPWR VPWR sky130_fd_sc_hd__decap_3
XFILLER_82_21 VGND VGND VPWR VPWR sky130_fd_sc_hd__decap_3
XTAP_TAPCELL_ROW_86_1379 VGND VPWR sky130_fd_sc_hd__tapvpwrvgnd_1
XFILLER_82_32 VGND VGND VPWR VPWR sky130_fd_sc_hd__decap_3
XFILLER_60_404 VGND VGND VPWR VPWR sky130_fd_sc_hd__decap_3
XFILLER_17_169 VGND VGND VPWR VPWR sky130_fd_sc_hd__fill_2
XFILLER_122_83 VGND VGND VPWR VPWR sky130_fd_sc_hd__fill_1
XFILLER_33_629 VGND VGND VPWR VPWR sky130_fd_sc_hd__decap_3
XFILLER_122_94 VGND VGND VPWR VPWR sky130_fd_sc_hd__decap_3
XTAP_TAPCELL_ROW_56_996 VGND VPWR sky130_fd_sc_hd__tapvpwrvgnd_1
XFILLER_26_681 VGND VGND VPWR VPWR sky130_fd_sc_hd__decap_3
XFILLER_72_297 VGND VGND VPWR VPWR sky130_fd_sc_hd__fill_2
XFILLER_60_448 VGND VGND VPWR VPWR sky130_fd_sc_hd__decap_3
XFILLER_25_191 VGND VGND VPWR VPWR sky130_fd_sc_hd__decap_3
XFILLER_41_662 VGND VGND VPWR VPWR sky130_fd_sc_hd__decap_3
XFILLER_13_353 VGND VGND VPWR VPWR sky130_fd_sc_hd__decap_3
XFILLER_41_673 VGND VGND VPWR VPWR sky130_fd_sc_hd__decap_3
XFILLER_9_368 VGND VGND VPWR VPWR sky130_fd_sc_hd__decap_3
XFILLER_70_9 VGND VGND VPWR VPWR sky130_fd_sc_hd__decap_3
XFILLER_5_552 VGND VGND VPWR VPWR sky130_fd_sc_hd__decap_3
XFILLER_114_417 VGND VGND VPWR VPWR sky130_fd_sc_hd__decap_3
XFILLER_5_585 VGND VGND VPWR VPWR sky130_fd_sc_hd__decap_3
XFILLER_107_491 VGND VGND VPWR VPWR sky130_fd_sc_hd__decap_3
XFILLER_122_450 VGND VGND VPWR VPWR sky130_fd_sc_hd__decap_3
XFILLER_95_301 VGND VGND VPWR VPWR sky130_fd_sc_hd__decap_3
XFILLER_68_515 VGND VGND VPWR VPWR sky130_fd_sc_hd__decap_3
XFILLER_110_601 VGND VGND VPWR VPWR sky130_fd_sc_hd__decap_3
XFILLER_68_526 VGND VGND VPWR VPWR sky130_fd_sc_hd__decap_3
XFILLER_122_483 VGND VGND VPWR VPWR sky130_fd_sc_hd__decap_3
XFILLER_110_634 VGND VGND VPWR VPWR sky130_fd_sc_hd__decap_3
X_4080_ _4075_/X _4079_/X _4425_/A VGND VGND VPWR VPWR _4451_/B sky130_fd_sc_hd__o21ai_2
XFILLER_110_645 VGND VGND VPWR VPWR sky130_fd_sc_hd__decap_3
XFILLER_68_559 VGND VGND VPWR VPWR sky130_fd_sc_hd__fill_2
XFILLER_110_678 VGND VGND VPWR VPWR sky130_fd_sc_hd__decap_3
XFILLER_64_710 VGND VGND VPWR VPWR sky130_fd_sc_hd__decap_3
XFILLER_76_570 VGND VGND VPWR VPWR sky130_fd_sc_hd__fill_1
XFILLER_76_592 VGND VGND VPWR VPWR sky130_fd_sc_hd__decap_3
XFILLER_24_607 VGND VGND VPWR VPWR sky130_fd_sc_hd__decap_3
XFILLER_36_467 VGND VGND VPWR VPWR sky130_fd_sc_hd__decap_3
XFILLER_91_573 VGND VGND VPWR VPWR sky130_fd_sc_hd__decap_3
XFILLER_63_264 VGND VGND VPWR VPWR sky130_fd_sc_hd__decap_3
X_4982_ _6992_/Q _4982_/B _5009_/A VGND VGND VPWR VPWR _4983_/C sky130_fd_sc_hd__or3_2
XFILLER_51_426 VGND VGND VPWR VPWR sky130_fd_sc_hd__decap_3
X_6721_ clkload4/A _6721_/D VGND VGND VPWR VPWR _6721_/Q sky130_fd_sc_hd__dfxtp_2
Xplace275 _3891_/B1 VGND VGND VPWR VPWR _3878_/B1 sky130_fd_sc_hd__buf_2
X_3933_ _7373_/Q _7341_/Q _3935_/S VGND VGND VPWR VPWR _7373_/D sky130_fd_sc_hd__mux2_2
Xplace286 _3906_/A2 VGND VGND VPWR VPWR _3898_/A2 sky130_fd_sc_hd__buf_2
XFILLER_32_640 VGND VGND VPWR VPWR sky130_fd_sc_hd__decap_3
Xplace297 _3656_/Y VGND VGND VPWR VPWR _3893_/B1 sky130_fd_sc_hd__buf_2
XFILLER_32_651 VGND VGND VPWR VPWR sky130_fd_sc_hd__decap_3
X_6652_ _6653_/A VGND VGND VPWR VPWR _6652_/Y sky130_fd_sc_hd__inv_2
X_3864_ _3864_/A0 _3863_/X _3904_/A VGND VGND VPWR VPWR _7385_/D sky130_fd_sc_hd__mux2_2
XFILLER_32_684 VGND VGND VPWR VPWR sky130_fd_sc_hd__decap_3
X_6583_ _6588_/A VGND VGND VPWR VPWR _6583_/Y sky130_fd_sc_hd__inv_2
XFILLER_118_701 VGND VGND VPWR VPWR sky130_fd_sc_hd__decap_3
X_3795_ _6971_/Q _3878_/A2 _3878_/B1 _6721_/Q VGND VGND VPWR VPWR _3795_/X sky130_fd_sc_hd__a22o_2
XFILLER_118_734 VGND VGND VPWR VPWR sky130_fd_sc_hd__fill_1
X_7204_ _7398_/CLK _7204_/D _6484_/Y VGND VGND VPWR VPWR _7204_/Q sky130_fd_sc_hd__dfrtp_2
X_4416_ _7368_/Q _4108_/B _4436_/B1 _7176_/Q _4415_/X VGND VGND VPWR VPWR _4416_/X
+ sky130_fd_sc_hd__a221o_2
X_5396_ _5396_/A0 _4978_/X _5398_/S VGND VGND VPWR VPWR _7135_/D sky130_fd_sc_hd__mux2_2
XFILLER_99_662 VGND VGND VPWR VPWR sky130_fd_sc_hd__decap_3
XFILLER_99_673 VGND VGND VPWR VPWR sky130_fd_sc_hd__decap_3
X_7135_ _7360_/CLK _7135_/D _6415_/Y VGND VGND VPWR VPWR _7135_/Q sky130_fd_sc_hd__dfrtp_2
X_4347_ _7289_/Q _4534_/S _4346_/X _4347_/C1 VGND VGND VPWR VPWR _4347_/X sky130_fd_sc_hd__a211o_2
XFILLER_101_612 VGND VGND VPWR VPWR sky130_fd_sc_hd__decap_3
XTAP_TAPCELL_ROW_6_349 VGND VPWR sky130_fd_sc_hd__tapvpwrvgnd_1
XFILLER_101_623 VGND VGND VPWR VPWR sky130_fd_sc_hd__decap_3
XFILLER_98_194 VGND VGND VPWR VPWR sky130_fd_sc_hd__fill_2
X_7066_ _7392_/CLK _7066_/D _6346_/Y VGND VGND VPWR VPWR _7066_/Q sky130_fd_sc_hd__dfrtp_2
X_4278_ _7286_/Q _4528_/B _4278_/B1 _7350_/Q _3556_/A VGND VGND VPWR VPWR _4278_/X
+ sky130_fd_sc_hd__a221o_2
XFILLER_101_656 VGND VGND VPWR VPWR sky130_fd_sc_hd__decap_3
XFILLER_39_261 VGND VGND VPWR VPWR sky130_fd_sc_hd__fill_1
XFILLER_100_177 VGND VGND VPWR VPWR sky130_fd_sc_hd__decap_3
XFILLER_55_721 VGND VGND VPWR VPWR sky130_fd_sc_hd__decap_3
XFILLER_55_732 VGND VGND VPWR VPWR sky130_fd_sc_hd__decap_3
XPHY_EDGE_ROW_6_Left_130 VGND VGND VPWR VPWR sky130_fd_sc_hd__decap_3
XFILLER_54_220 VGND VGND VPWR VPWR sky130_fd_sc_hd__decap_3
XFILLER_27_456 VGND VGND VPWR VPWR sky130_fd_sc_hd__decap_3
XFILLER_82_562 VGND VGND VPWR VPWR sky130_fd_sc_hd__decap_3
XFILLER_54_253 VGND VGND VPWR VPWR sky130_fd_sc_hd__decap_3
XFILLER_70_713 VGND VGND VPWR VPWR sky130_fd_sc_hd__decap_3
XFILLER_15_629 VGND VGND VPWR VPWR sky130_fd_sc_hd__decap_3
XFILLER_54_275 VGND VGND VPWR VPWR sky130_fd_sc_hd__decap_3
XFILLER_82_595 VGND VGND VPWR VPWR sky130_fd_sc_hd__decap_3
XTAP_TAPCELL_ROW_53_955 VGND VPWR sky130_fd_sc_hd__tapvpwrvgnd_1
X_6919_ _6942_/CLK _6919_/D VGND VGND VPWR VPWR _6919_/Q sky130_fd_sc_hd__dfxtp_2
XFILLER_23_662 VGND VGND VPWR VPWR sky130_fd_sc_hd__decap_3
XFILLER_23_673 VGND VGND VPWR VPWR sky130_fd_sc_hd__decap_3
XFILLER_10_301 VGND VGND VPWR VPWR sky130_fd_sc_hd__decap_3
XTAP_TAPCELL_ROW_33_690 VGND VPWR sky130_fd_sc_hd__tapvpwrvgnd_1
XFILLER_10_334 VGND VGND VPWR VPWR sky130_fd_sc_hd__decap_3
XFILLER_6_305 VGND VGND VPWR VPWR sky130_fd_sc_hd__decap_3
XFILLER_109_712 VGND VGND VPWR VPWR sky130_fd_sc_hd__decap_3
XFILLER_108_211 VGND VGND VPWR VPWR sky130_fd_sc_hd__decap_3
XFILLER_10_389 VGND VGND VPWR VPWR sky130_fd_sc_hd__decap_3
XFILLER_108_288 VGND VGND VPWR VPWR sky130_fd_sc_hd__fill_2
XFILLER_2_522 VGND VGND VPWR VPWR sky130_fd_sc_hd__decap_3
XFILLER_2_533 VGND VGND VPWR VPWR sky130_fd_sc_hd__decap_3
XFILLER_123_236 VGND VGND VPWR VPWR sky130_fd_sc_hd__fill_1
XFILLER_77_21 VGND VGND VPWR VPWR sky130_fd_sc_hd__decap_3
XFILLER_2_566 VGND VGND VPWR VPWR sky130_fd_sc_hd__decap_3
XFILLER_117_72 VGND VGND VPWR VPWR sky130_fd_sc_hd__decap_3
XFILLER_89_183 VGND VGND VPWR VPWR sky130_fd_sc_hd__decap_3
XFILLER_77_323 VGND VGND VPWR VPWR sky130_fd_sc_hd__decap_3
XFILLER_77_356 VGND VGND VPWR VPWR sky130_fd_sc_hd__decap_3
XTAP_TAPCELL_ROW_88_1408 VGND VPWR sky130_fd_sc_hd__tapvpwrvgnd_1
XFILLER_65_529 VGND VGND VPWR VPWR sky130_fd_sc_hd__decap_3
XFILLER_46_710 VGND VGND VPWR VPWR sky130_fd_sc_hd__decap_3
XFILLER_58_581 VGND VGND VPWR VPWR sky130_fd_sc_hd__decap_3
XFILLER_92_337 VGND VGND VPWR VPWR sky130_fd_sc_hd__fill_2
XFILLER_58_592 VGND VGND VPWR VPWR sky130_fd_sc_hd__fill_1
XFILLER_45_220 VGND VGND VPWR VPWR sky130_fd_sc_hd__decap_3
XFILLER_18_445 VGND VGND VPWR VPWR sky130_fd_sc_hd__decap_3
Xhold1090 _7295_/Q VGND VGND VPWR VPWR _4571_/A sky130_fd_sc_hd__dlygate4sd3_1
XFILLER_93_86 VGND VGND VPWR VPWR sky130_fd_sc_hd__fill_2
XFILLER_61_724 VGND VGND VPWR VPWR sky130_fd_sc_hd__decap_3
XFILLER_60_212 VGND VGND VPWR VPWR sky130_fd_sc_hd__decap_3
XFILLER_26_91 VGND VGND VPWR VPWR sky130_fd_sc_hd__decap_3
XFILLER_14_640 VGND VGND VPWR VPWR sky130_fd_sc_hd__decap_3
XFILLER_60_256 VGND VGND VPWR VPWR sky130_fd_sc_hd__decap_3
XFILLER_14_651 VGND VGND VPWR VPWR sky130_fd_sc_hd__decap_3
XFILLER_60_289 VGND VGND VPWR VPWR sky130_fd_sc_hd__decap_3
XFILLER_14_684 VGND VGND VPWR VPWR sky130_fd_sc_hd__decap_3
XFILLER_13_161 VGND VGND VPWR VPWR sky130_fd_sc_hd__decap_3
XTAP_TAPCELL_ROW_99_1548 VGND VPWR sky130_fd_sc_hd__tapvpwrvgnd_1
XTAP_TAPCELL_ROW_99_1559 VGND VPWR sky130_fd_sc_hd__tapvpwrvgnd_1
XFILLER_9_198 VGND VGND VPWR VPWR sky130_fd_sc_hd__fill_1
X_3580_ _7033_/Q _3488_/B _4278_/B1 _7380_/Q VGND VGND VPWR VPWR _3580_/X sky130_fd_sc_hd__a22o_2
XFILLER_115_715 VGND VGND VPWR VPWR sky130_fd_sc_hd__decap_3
XFILLER_114_203 VGND VGND VPWR VPWR sky130_fd_sc_hd__decap_3
XFILLER_47_3 VGND VGND VPWR VPWR sky130_fd_sc_hd__fill_1
X_4201_ _4186_/A _4636_/B _4200_/X VGND VGND VPWR VPWR _4201_/X sky130_fd_sc_hd__o21a_2
XFILLER_87_109 VGND VGND VPWR VPWR sky130_fd_sc_hd__decap_3
XFILLER_96_610 VGND VGND VPWR VPWR sky130_fd_sc_hd__decap_3
XFILLER_68_312 VGND VGND VPWR VPWR sky130_fd_sc_hd__decap_3
X_4132_ _7075_/Q _4265_/B _4432_/B1 _4131_/X VGND VGND VPWR VPWR _4207_/A sky130_fd_sc_hd__o211ai_2
XFILLER_96_643 VGND VGND VPWR VPWR sky130_fd_sc_hd__fill_1
XFILLER_95_120 VGND VGND VPWR VPWR sky130_fd_sc_hd__decap_3
XFILLER_96_654 VGND VGND VPWR VPWR sky130_fd_sc_hd__decap_3
XTAP_TAPCELL_ROW_3_308 VGND VPWR sky130_fd_sc_hd__tapvpwrvgnd_1
XFILLER_95_153 VGND VGND VPWR VPWR sky130_fd_sc_hd__decap_3
XFILLER_96_687 VGND VGND VPWR VPWR sky130_fd_sc_hd__decap_3
X_4063_ _7116_/Q _4434_/A2 _4434_/B1 _7148_/Q VGND VGND VPWR VPWR _4063_/X sky130_fd_sc_hd__a22o_2
XFILLER_37_721 VGND VGND VPWR VPWR sky130_fd_sc_hd__decap_3
XFILLER_83_337 VGND VGND VPWR VPWR sky130_fd_sc_hd__decap_3
XFILLER_95_197 VGND VGND VPWR VPWR sky130_fd_sc_hd__fill_1
XFILLER_37_732 VGND VGND VPWR VPWR sky130_fd_sc_hd__decap_3
XTAP_TAPCELL_ROW_108_1666 VGND VPWR sky130_fd_sc_hd__tapvpwrvgnd_1
XFILLER_36_253 VGND VGND VPWR VPWR sky130_fd_sc_hd__decap_3
XTAP_TAPCELL_ROW_108_1677 VGND VPWR sky130_fd_sc_hd__tapvpwrvgnd_1
XFILLER_52_713 VGND VGND VPWR VPWR sky130_fd_sc_hd__decap_3
XFILLER_64_584 VGND VGND VPWR VPWR sky130_fd_sc_hd__decap_3
XFILLER_64_595 VGND VGND VPWR VPWR sky130_fd_sc_hd__decap_3
XTAP_TAPCELL_ROW_121_1844 VGND VPWR sky130_fd_sc_hd__tapvpwrvgnd_1
X_4965_ _4965_/A0 _4964_/X _5028_/S VGND VGND VPWR VPWR _7264_/D sky130_fd_sc_hd__mux2_2
XTAP_TAPCELL_ROW_50_914 VGND VPWR sky130_fd_sc_hd__tapvpwrvgnd_1
X_6704_ _7392_/CLK _6704_/D VGND VGND VPWR VPWR _6704_/Q sky130_fd_sc_hd__dfxtp_2
XFILLER_11_109 VGND VGND VPWR VPWR sky130_fd_sc_hd__decap_3
XFILLER_20_610 VGND VGND VPWR VPWR sky130_fd_sc_hd__decap_3
X_4896_ _4896_/A _4896_/B VGND VGND VPWR VPWR _4896_/Y sky130_fd_sc_hd__nand2_2
XFILLER_32_492 VGND VGND VPWR VPWR sky130_fd_sc_hd__decap_3
XFILLER_20_643 VGND VGND VPWR VPWR sky130_fd_sc_hd__fill_1
X_6635_ _6635_/A VGND VGND VPWR VPWR _6635_/Y sky130_fd_sc_hd__inv_2
X_3847_ _6946_/Q _5660_/B _3891_/B1 _6958_/Q _3846_/X VGND VGND VPWR VPWR _3847_/X
+ sky130_fd_sc_hd__a221o_2
XFILLER_20_654 VGND VGND VPWR VPWR sky130_fd_sc_hd__decap_3
XTAP_TAPCELL_ROW_30_660 VGND VPWR sky130_fd_sc_hd__tapvpwrvgnd_1
XFILLER_20_687 VGND VGND VPWR VPWR sky130_fd_sc_hd__decap_3
X_6566_ _6566_/A VGND VGND VPWR VPWR _6566_/Y sky130_fd_sc_hd__inv_2
XFILLER_118_531 VGND VGND VPWR VPWR sky130_fd_sc_hd__fill_1
X_3778_ _6930_/Q _3906_/A2 _3871_/B1 _6882_/Q VGND VGND VPWR VPWR _3778_/X sky130_fd_sc_hd__a22o_2
XFILLER_118_542 VGND VGND VPWR VPWR sky130_fd_sc_hd__decap_3
XFILLER_118_9 VGND VGND VPWR VPWR sky130_fd_sc_hd__decap_3
XFILLER_106_704 VGND VGND VPWR VPWR sky130_fd_sc_hd__decap_3
XFILLER_118_575 VGND VGND VPWR VPWR sky130_fd_sc_hd__decap_3
X_6497_ _6635_/A VGND VGND VPWR VPWR _6497_/Y sky130_fd_sc_hd__inv_2
XFILLER_105_225 VGND VGND VPWR VPWR sky130_fd_sc_hd__decap_3
XTAP_TAPCELL_ROW_72_1209 VGND VPWR sky130_fd_sc_hd__tapvpwrvgnd_1
XFILLER_105_247 VGND VGND VPWR VPWR sky130_fd_sc_hd__decap_3
Xoutput462 _5658_/A VGND VGND VPWR VPWR alu_result_out[10] sky130_fd_sc_hd__clkdlybuf4s25_1
XFILLER_121_718 VGND VGND VPWR VPWR sky130_fd_sc_hd__decap_3
XFILLER_105_269 VGND VGND VPWR VPWR sky130_fd_sc_hd__decap_3
Xoutput473 _5657_/B VGND VGND VPWR VPWR alu_result_out[20] sky130_fd_sc_hd__clkdlybuf4s25_1
XFILLER_78_109 VGND VGND VPWR VPWR sky130_fd_sc_hd__decap_3
XFILLER_121_729 VGND VGND VPWR VPWR sky130_fd_sc_hd__decap_3
Xoutput484 _5655_/A VGND VGND VPWR VPWR alu_result_out[30] sky130_fd_sc_hd__clkdlybuf4s25_1
XFILLER_59_301 VGND VGND VPWR VPWR sky130_fd_sc_hd__fill_1
X_5379_ _5379_/A0 _4836_/X _5383_/S VGND VGND VPWR VPWR _7143_/D sky130_fd_sc_hd__mux2_2
Xoutput495 _5645_/X VGND VGND VPWR VPWR instruction_out[12] sky130_fd_sc_hd__clkdlybuf4s25_1
XFILLER_87_632 VGND VGND VPWR VPWR sky130_fd_sc_hd__decap_3
X_7118_ _7368_/CLK _7118_/D _6398_/Y VGND VGND VPWR VPWR _7118_/Q sky130_fd_sc_hd__dfrtp_2
XFILLER_86_120 VGND VGND VPWR VPWR sky130_fd_sc_hd__fill_1
XFILLER_101_431 VGND VGND VPWR VPWR sky130_fd_sc_hd__decap_3
XFILLER_87_665 VGND VGND VPWR VPWR sky130_fd_sc_hd__decap_3
XFILLER_87_676 VGND VGND VPWR VPWR sky130_fd_sc_hd__decap_3
XFILLER_47_518 VGND VGND VPWR VPWR sky130_fd_sc_hd__fill_2
XFILLER_19_209 VGND VGND VPWR VPWR sky130_fd_sc_hd__decap_3
XFILLER_101_464 VGND VGND VPWR VPWR sky130_fd_sc_hd__decap_3
X_7049_ _7398_/CLK _7049_/D _6329_/Y VGND VGND VPWR VPWR _7049_/Q sky130_fd_sc_hd__dfrtp_2
XPHY_EDGE_ROW_29_Right_29 VGND VGND VPWR VPWR sky130_fd_sc_hd__decap_3
XFILLER_86_175 VGND VGND VPWR VPWR sky130_fd_sc_hd__decap_3
XFILLER_47_57 VGND VGND VPWR VPWR sky130_fd_sc_hd__decap_3
XFILLER_28_710 VGND VGND VPWR VPWR sky130_fd_sc_hd__decap_3
XFILLER_86_197 VGND VGND VPWR VPWR sky130_fd_sc_hd__fill_1
XFILLER_74_348 VGND VGND VPWR VPWR sky130_fd_sc_hd__decap_3
XFILLER_55_540 VGND VGND VPWR VPWR sky130_fd_sc_hd__decap_3
XFILLER_27_231 VGND VGND VPWR VPWR sky130_fd_sc_hd__decap_3
XFILLER_103_30 VGND VGND VPWR VPWR sky130_fd_sc_hd__fill_2
XTAP_TAPCELL_ROW_38_760 VGND VPWR sky130_fd_sc_hd__tapvpwrvgnd_1
XFILLER_103_52 VGND VGND VPWR VPWR sky130_fd_sc_hd__decap_3
XFILLER_43_724 VGND VGND VPWR VPWR sky130_fd_sc_hd__decap_3
XFILLER_63_23 VGND VGND VPWR VPWR sky130_fd_sc_hd__decap_3
XFILLER_27_275 VGND VGND VPWR VPWR sky130_fd_sc_hd__decap_3
XFILLER_42_212 VGND VGND VPWR VPWR sky130_fd_sc_hd__decap_3
XFILLER_63_34 VGND VGND VPWR VPWR sky130_fd_sc_hd__decap_3
XTAP_TAPCELL_ROW_83_1349 VGND VPWR sky130_fd_sc_hd__tapvpwrvgnd_1
XFILLER_15_459 VGND VGND VPWR VPWR sky130_fd_sc_hd__fill_2
XFILLER_63_78 VGND VGND VPWR VPWR sky130_fd_sc_hd__decap_3
XFILLER_42_256 VGND VGND VPWR VPWR sky130_fd_sc_hd__decap_3
XFILLER_70_587 VGND VGND VPWR VPWR sky130_fd_sc_hd__fill_1
XFILLER_30_418 VGND VGND VPWR VPWR sky130_fd_sc_hd__fill_2
XFILLER_70_598 VGND VGND VPWR VPWR sky130_fd_sc_hd__decap_3
XFILLER_23_470 VGND VGND VPWR VPWR sky130_fd_sc_hd__decap_3
XFILLER_11_632 VGND VGND VPWR VPWR sky130_fd_sc_hd__decap_3
XFILLER_7_603 VGND VGND VPWR VPWR sky130_fd_sc_hd__decap_3
XFILLER_10_131 VGND VGND VPWR VPWR sky130_fd_sc_hd__fill_1
XPHY_EDGE_ROW_38_Right_38 VGND VGND VPWR VPWR sky130_fd_sc_hd__decap_3
XFILLER_11_665 VGND VGND VPWR VPWR sky130_fd_sc_hd__decap_3
XFILLER_11_676 VGND VGND VPWR VPWR sky130_fd_sc_hd__decap_3
XFILLER_7_647 VGND VGND VPWR VPWR sky130_fd_sc_hd__decap_3
XFILLER_109_531 VGND VGND VPWR VPWR sky130_fd_sc_hd__decap_3
XFILLER_10_197 VGND VGND VPWR VPWR sky130_fd_sc_hd__decap_3
XFILLER_109_564 VGND VGND VPWR VPWR sky130_fd_sc_hd__decap_3
XFILLER_109_597 VGND VGND VPWR VPWR sky130_fd_sc_hd__decap_3
XTAP_TAPCELL_ROW_94_1489 VGND VPWR sky130_fd_sc_hd__tapvpwrvgnd_1
XFILLER_112_707 VGND VGND VPWR VPWR sky130_fd_sc_hd__decap_3
XFILLER_111_206 VGND VGND VPWR VPWR sky130_fd_sc_hd__decap_3
XFILLER_78_610 VGND VGND VPWR VPWR sky130_fd_sc_hd__decap_3
XFILLER_88_97 VGND VGND VPWR VPWR sky130_fd_sc_hd__decap_3
XFILLER_111_228 VGND VGND VPWR VPWR sky130_fd_sc_hd__fill_1
XFILLER_78_643 VGND VGND VPWR VPWR sky130_fd_sc_hd__fill_1
XFILLER_78_654 VGND VGND VPWR VPWR sky130_fd_sc_hd__decap_3
XPHY_EDGE_ROW_47_Right_47 VGND VGND VPWR VPWR sky130_fd_sc_hd__decap_3
XFILLER_77_153 VGND VGND VPWR VPWR sky130_fd_sc_hd__decap_3
XFILLER_78_687 VGND VGND VPWR VPWR sky130_fd_sc_hd__decap_3
XFILLER_77_175 VGND VGND VPWR VPWR sky130_fd_sc_hd__decap_3
XFILLER_93_635 VGND VGND VPWR VPWR sky130_fd_sc_hd__decap_3
XFILLER_92_112 VGND VGND VPWR VPWR sky130_fd_sc_hd__decap_3
XFILLER_19_721 VGND VGND VPWR VPWR sky130_fd_sc_hd__decap_3
XFILLER_65_337 VGND VGND VPWR VPWR sky130_fd_sc_hd__decap_3
XFILLER_19_732 VGND VGND VPWR VPWR sky130_fd_sc_hd__decap_3
XFILLER_93_668 VGND VGND VPWR VPWR sky130_fd_sc_hd__decap_3
XFILLER_93_679 VGND VGND VPWR VPWR sky130_fd_sc_hd__decap_3
XFILLER_80_307 VGND VGND VPWR VPWR sky130_fd_sc_hd__fill_1
XFILLER_80_318 VGND VGND VPWR VPWR sky130_fd_sc_hd__decap_3
XFILLER_18_253 VGND VGND VPWR VPWR sky130_fd_sc_hd__decap_3
XFILLER_34_713 VGND VGND VPWR VPWR sky130_fd_sc_hd__decap_3
XFILLER_92_189 VGND VGND VPWR VPWR sky130_fd_sc_hd__decap_3
XFILLER_46_584 VGND VGND VPWR VPWR sky130_fd_sc_hd__decap_3
XFILLER_33_223 VGND VGND VPWR VPWR sky130_fd_sc_hd__fill_1
XFILLER_61_554 VGND VGND VPWR VPWR sky130_fd_sc_hd__fill_1
XFILLER_33_256 VGND VGND VPWR VPWR sky130_fd_sc_hd__decap_3
XTAP_TAPCELL_ROW_16_476 VGND VPWR sky130_fd_sc_hd__tapvpwrvgnd_1
X_4750_ _4909_/A _4750_/B _4750_/C VGND VGND VPWR VPWR _4751_/B sky130_fd_sc_hd__or3_2
XPHY_EDGE_ROW_56_Right_56 VGND VGND VPWR VPWR sky130_fd_sc_hd__decap_3
XPHY_EDGE_ROW_78_Left_202 VGND VGND VPWR VPWR sky130_fd_sc_hd__decap_3
X_3701_ _3682_/A _3700_/X _4791_/A1 VGND VGND VPWR VPWR _3701_/X sky130_fd_sc_hd__a21o_2
XFILLER_119_306 VGND VGND VPWR VPWR sky130_fd_sc_hd__fill_1
X_4681_ _4982_/B _5009_/A _6992_/Q _6993_/Q _6994_/Q VGND VGND VPWR VPWR _4960_/B
+ sky130_fd_sc_hd__o2111a_2
X_6420_ _6610_/A VGND VGND VPWR VPWR _6420_/Y sky130_fd_sc_hd__inv_2
X_3632_ _3630_/A _3501_/X _3502_/X _3505_/B _5020_/A VGND VGND VPWR VPWR _3632_/X
+ sky130_fd_sc_hd__a311o_2
X_6351_ _6674_/A VGND VGND VPWR VPWR _6351_/Y sky130_fd_sc_hd__inv_2
XTAP_TAPCELL_ROW_58_1020 VGND VPWR sky130_fd_sc_hd__tapvpwrvgnd_1
XFILLER_115_523 VGND VGND VPWR VPWR sky130_fd_sc_hd__decap_3
X_5302_ _5302_/A0 _4771_/X _5315_/S VGND VGND VPWR VPWR _7179_/D sky130_fd_sc_hd__mux2_2
X_6282_ _6462_/A VGND VGND VPWR VPWR _6282_/Y sky130_fd_sc_hd__inv_2
XFILLER_115_556 VGND VGND VPWR VPWR sky130_fd_sc_hd__decap_3
X_3494_ _7183_/Q _4471_/S _4354_/B1 _7375_/Q VGND VGND VPWR VPWR _3494_/X sky130_fd_sc_hd__a22o_2
XFILLER_88_407 VGND VGND VPWR VPWR sky130_fd_sc_hd__decap_3
XFILLER_115_567 VGND VGND VPWR VPWR sky130_fd_sc_hd__decap_3
XFILLER_103_718 VGND VGND VPWR VPWR sky130_fd_sc_hd__decap_3
XFILLER_103_729 VGND VGND VPWR VPWR sky130_fd_sc_hd__decap_3
XPHY_EDGE_ROW_65_Right_65 VGND VGND VPWR VPWR sky130_fd_sc_hd__decap_3
XPHY_EDGE_ROW_87_Left_211 VGND VGND VPWR VPWR sky130_fd_sc_hd__decap_3
XFILLER_69_632 VGND VGND VPWR VPWR sky130_fd_sc_hd__decap_3
XFILLER_69_665 VGND VGND VPWR VPWR sky130_fd_sc_hd__decap_3
XFILLER_69_676 VGND VGND VPWR VPWR sky130_fd_sc_hd__decap_3
X_4115_ _7268_/Q _4422_/A2 _4421_/A2 _7236_/Q _4114_/X VGND VGND VPWR VPWR _4117_/B
+ sky130_fd_sc_hd__a221o_2
XFILLER_84_613 VGND VGND VPWR VPWR sky130_fd_sc_hd__decap_3
X_5095_ _5095_/A0 _5094_/X _5157_/S VGND VGND VPWR VPWR _7256_/D sky130_fd_sc_hd__mux2_2
XFILLER_96_495 VGND VGND VPWR VPWR sky130_fd_sc_hd__decap_3
XFILLER_68_197 VGND VGND VPWR VPWR sky130_fd_sc_hd__decap_3
XFILLER_84_657 VGND VGND VPWR VPWR sky130_fd_sc_hd__decap_3
X_4046_ _7373_/Q _4394_/B _4436_/B1 _7181_/Q VGND VGND VPWR VPWR _4046_/X sky130_fd_sc_hd__a22o_2
XFILLER_83_156 VGND VGND VPWR VPWR sky130_fd_sc_hd__decap_3
XTAP_TAPCELL_ROW_69_1160 VGND VPWR sky130_fd_sc_hd__tapvpwrvgnd_1
XFILLER_25_724 VGND VGND VPWR VPWR sky130_fd_sc_hd__decap_3
XFILLER_92_690 VGND VGND VPWR VPWR sky130_fd_sc_hd__decap_3
XFILLER_24_223 VGND VGND VPWR VPWR sky130_fd_sc_hd__decap_3
XFILLER_24_245 VGND VGND VPWR VPWR sky130_fd_sc_hd__decap_3
XPHY_EDGE_ROW_74_Right_74 VGND VGND VPWR VPWR sky130_fd_sc_hd__decap_3
XPHY_EDGE_ROW_96_Left_220 VGND VGND VPWR VPWR sky130_fd_sc_hd__decap_3
XFILLER_24_256 VGND VGND VPWR VPWR sky130_fd_sc_hd__decap_3
XFILLER_40_716 VGND VGND VPWR VPWR sky130_fd_sc_hd__decap_3
XFILLER_24_289 VGND VGND VPWR VPWR sky130_fd_sc_hd__decap_3
X_4948_ _4948_/A _4948_/B VGND VGND VPWR VPWR _4948_/Y sky130_fd_sc_hd__nor2_2
X_4879_ _4879_/A0 _4878_/X _4914_/S VGND VGND VPWR VPWR _7269_/D sky130_fd_sc_hd__mux2_2
X_6618_ _6618_/A VGND VGND VPWR VPWR _6618_/Y sky130_fd_sc_hd__inv_2
X_6549_ _6654_/A VGND VGND VPWR VPWR _6549_/Y sky130_fd_sc_hd__inv_2
XFILLER_4_628 VGND VGND VPWR VPWR sky130_fd_sc_hd__decap_3
XFILLER_106_523 VGND VGND VPWR VPWR sky130_fd_sc_hd__decap_3
XFILLER_106_545 VGND VGND VPWR VPWR sky130_fd_sc_hd__decap_3
XPHY_EDGE_ROW_83_Right_83 VGND VGND VPWR VPWR sky130_fd_sc_hd__decap_3
XFILLER_106_578 VGND VGND VPWR VPWR sky130_fd_sc_hd__decap_3
XFILLER_106_589 VGND VGND VPWR VPWR sky130_fd_sc_hd__decap_3
XFILLER_121_526 VGND VGND VPWR VPWR sky130_fd_sc_hd__decap_3
XFILLER_58_45 VGND VGND VPWR VPWR sky130_fd_sc_hd__decap_3
XFILLER_121_559 VGND VGND VPWR VPWR sky130_fd_sc_hd__fill_1
XFILLER_87_462 VGND VGND VPWR VPWR sky130_fd_sc_hd__decap_3
XFILLER_75_635 VGND VGND VPWR VPWR sky130_fd_sc_hd__decap_3
XFILLER_47_337 VGND VGND VPWR VPWR sky130_fd_sc_hd__decap_3
XFILLER_114_62 VGND VGND VPWR VPWR sky130_fd_sc_hd__decap_3
XFILLER_75_668 VGND VGND VPWR VPWR sky130_fd_sc_hd__decap_3
XFILLER_75_679 VGND VGND VPWR VPWR sky130_fd_sc_hd__decap_3
XFILLER_74_156 VGND VGND VPWR VPWR sky130_fd_sc_hd__decap_3
XFILLER_90_616 VGND VGND VPWR VPWR sky130_fd_sc_hd__decap_3
XFILLER_62_307 VGND VGND VPWR VPWR sky130_fd_sc_hd__fill_1
XFILLER_28_562 VGND VGND VPWR VPWR sky130_fd_sc_hd__decap_3
XFILLER_62_318 VGND VGND VPWR VPWR sky130_fd_sc_hd__decap_3
XFILLER_16_713 VGND VGND VPWR VPWR sky130_fd_sc_hd__decap_3
XFILLER_55_370 VGND VGND VPWR VPWR sky130_fd_sc_hd__fill_1
XFILLER_28_595 VGND VGND VPWR VPWR sky130_fd_sc_hd__decap_3
XFILLER_15_212 VGND VGND VPWR VPWR sky130_fd_sc_hd__fill_1
XPHY_EDGE_ROW_92_Right_92 VGND VGND VPWR VPWR sky130_fd_sc_hd__decap_3
XFILLER_43_532 VGND VGND VPWR VPWR sky130_fd_sc_hd__decap_3
XFILLER_74_99 VGND VGND VPWR VPWR sky130_fd_sc_hd__decap_3
XFILLER_70_351 VGND VGND VPWR VPWR sky130_fd_sc_hd__decap_3
XFILLER_15_256 VGND VGND VPWR VPWR sky130_fd_sc_hd__decap_3
XFILLER_31_727 VGND VGND VPWR VPWR sky130_fd_sc_hd__fill_1
XFILLER_90_32 VGND VGND VPWR VPWR sky130_fd_sc_hd__decap_3
XTAP_TAPCELL_ROW_13_435 VGND VPWR sky130_fd_sc_hd__tapvpwrvgnd_1
XFILLER_30_259 VGND VGND VPWR VPWR sky130_fd_sc_hd__decap_3
XFILLER_7_411 VGND VGND VPWR VPWR sky130_fd_sc_hd__decap_3
XTAP_TAPCELL_ROW_41_799 VGND VPWR sky130_fd_sc_hd__tapvpwrvgnd_1
XTAP_TAPCELL_ROW_96_1518 VGND VPWR sky130_fd_sc_hd__tapvpwrvgnd_1
XFILLER_116_309 VGND VGND VPWR VPWR sky130_fd_sc_hd__decap_3
XFILLER_99_63 VGND VGND VPWR VPWR sky130_fd_sc_hd__decap_3
XFILLER_109_383 VGND VGND VPWR VPWR sky130_fd_sc_hd__decap_3
XFILLER_98_716 VGND VGND VPWR VPWR sky130_fd_sc_hd__decap_3
XFILLER_3_650 VGND VGND VPWR VPWR sky130_fd_sc_hd__decap_3
XFILLER_112_504 VGND VGND VPWR VPWR sky130_fd_sc_hd__decap_3
XFILLER_3_694 VGND VGND VPWR VPWR sky130_fd_sc_hd__decap_3
XFILLER_112_548 VGND VGND VPWR VPWR sky130_fd_sc_hd__decap_3
XFILLER_38_304 VGND VGND VPWR VPWR sky130_fd_sc_hd__decap_3
XFILLER_66_624 VGND VGND VPWR VPWR sky130_fd_sc_hd__decap_3
XFILLER_78_495 VGND VGND VPWR VPWR sky130_fd_sc_hd__decap_3
XFILLER_120_581 VGND VGND VPWR VPWR sky130_fd_sc_hd__decap_3
XFILLER_65_123 VGND VGND VPWR VPWR sky130_fd_sc_hd__decap_3
XFILLER_120_592 VGND VGND VPWR VPWR sky130_fd_sc_hd__decap_3
XFILLER_66_657 VGND VGND VPWR VPWR sky130_fd_sc_hd__decap_3
XFILLER_38_348 VGND VGND VPWR VPWR sky130_fd_sc_hd__decap_3
XFILLER_93_476 VGND VGND VPWR VPWR sky130_fd_sc_hd__decap_3
XTAP_TAPCELL_ROW_49_899 VGND VPWR sky130_fd_sc_hd__tapvpwrvgnd_1
XFILLER_19_573 VGND VGND VPWR VPWR sky130_fd_sc_hd__decap_3
XFILLER_93_498 VGND VGND VPWR VPWR sky130_fd_sc_hd__decap_3
XFILLER_81_638 VGND VGND VPWR VPWR sky130_fd_sc_hd__decap_3
XFILLER_74_690 VGND VGND VPWR VPWR sky130_fd_sc_hd__decap_3
XTAP_TAPCELL_ROW_105_1636 VGND VPWR sky130_fd_sc_hd__tapvpwrvgnd_1
XFILLER_46_392 VGND VGND VPWR VPWR sky130_fd_sc_hd__decap_3
XFILLER_0_85 VGND VGND VPWR VPWR sky130_fd_sc_hd__fill_2
XFILLER_61_340 VGND VGND VPWR VPWR sky130_fd_sc_hd__decap_3
XFILLER_22_716 VGND VGND VPWR VPWR sky130_fd_sc_hd__decap_3
XPHY_EDGE_ROW_100_Right_100 VGND VGND VPWR VPWR sky130_fd_sc_hd__decap_3
X_4802_ _7002_/Q _4690_/B _4834_/A VGND VGND VPWR VPWR _4802_/X sky130_fd_sc_hd__o21a_2
XFILLER_34_598 VGND VGND VPWR VPWR sky130_fd_sc_hd__decap_3
XFILLER_21_237 VGND VGND VPWR VPWR sky130_fd_sc_hd__decap_3
XFILLER_119_18 VGND VGND VPWR VPWR sky130_fd_sc_hd__decap_3
X_4664_ _4983_/A _4664_/B _5665_/A VGND VGND VPWR VPWR _4664_/X sky130_fd_sc_hd__or3b_4
X_6403_ _6596_/A VGND VGND VPWR VPWR _6403_/Y sky130_fd_sc_hd__inv_2
XFILLER_119_169 VGND VGND VPWR VPWR sky130_fd_sc_hd__decap_3
X_3615_ _3508_/A _3547_/Y _3427_/B VGND VGND VPWR VPWR _3616_/B sky130_fd_sc_hd__o21ai_2
X_7383_ _7386_/CLK _7383_/D _6663_/Y VGND VGND VPWR VPWR _7383_/Q sky130_fd_sc_hd__dfrtp_2
X_4595_ _4595_/A _4595_/B VGND VGND VPWR VPWR _7283_/D sky130_fd_sc_hd__and2_2
Xhold901 _7095_/Q VGND VGND VPWR VPWR _7095_/D sky130_fd_sc_hd__dlygate4sd3_1
Xhold912 _6689_/Q VGND VGND VPWR VPWR hold912/X sky130_fd_sc_hd__dlygate4sd3_1
Xhold923 _6711_/Q VGND VGND VPWR VPWR hold923/X sky130_fd_sc_hd__dlygate4sd3_1
XFILLER_115_320 VGND VGND VPWR VPWR sky130_fd_sc_hd__decap_3
X_6334_ _6650_/A VGND VGND VPWR VPWR _6334_/Y sky130_fd_sc_hd__inv_2
Xhold934 _7046_/Q VGND VGND VPWR VPWR hold934/X sky130_fd_sc_hd__dlygate4sd3_1
X_3546_ _3630_/A _3630_/B _3635_/A _3636_/A VGND VGND VPWR VPWR _3547_/B sky130_fd_sc_hd__a211o_2
Xhold945 _7392_/Q VGND VGND VPWR VPWR hold945/X sky130_fd_sc_hd__dlygate4sd3_1
XTAP_TAPCELL_ROW_116_1776 VGND VPWR sky130_fd_sc_hd__tapvpwrvgnd_1
Xhold956 _7027_/Q VGND VGND VPWR VPWR _5600_/A sky130_fd_sc_hd__dlygate4sd3_1
XFILLER_1_609 VGND VGND VPWR VPWR sky130_fd_sc_hd__decap_3
XFILLER_115_353 VGND VGND VPWR VPWR sky130_fd_sc_hd__decap_3
Xhold967 _7044_/Q VGND VGND VPWR VPWR hold967/X sky130_fd_sc_hd__dlygate4sd3_1
XFILLER_89_727 VGND VGND VPWR VPWR sky130_fd_sc_hd__fill_1
Xhold978 _7320_/Q VGND VGND VPWR VPWR hold978/X sky130_fd_sc_hd__dlygate4sd3_1
X_6265_ _6674_/A VGND VGND VPWR VPWR _6265_/Y sky130_fd_sc_hd__inv_2
Xhold989 _7241_/Q VGND VGND VPWR VPWR _5173_/A sky130_fd_sc_hd__dlygate4sd3_1
X_3477_ _7184_/Q _3996_/S _3380_/Y _7376_/Q VGND VGND VPWR VPWR _3477_/X sky130_fd_sc_hd__a22o_2
XFILLER_88_226 VGND VGND VPWR VPWR sky130_fd_sc_hd__decap_3
XFILLER_103_559 VGND VGND VPWR VPWR sky130_fd_sc_hd__fill_1
XFILLER_69_473 VGND VGND VPWR VPWR sky130_fd_sc_hd__decap_3
XFILLER_29_304 VGND VGND VPWR VPWR sky130_fd_sc_hd__decap_3
X_5147_ _5145_/A _3541_/X _5146_/Y VGND VGND VPWR VPWR _5147_/X sky130_fd_sc_hd__a21o_2
XFILLER_111_570 VGND VGND VPWR VPWR sky130_fd_sc_hd__decap_3
XFILLER_69_495 VGND VGND VPWR VPWR sky130_fd_sc_hd__decap_3
XFILLER_57_635 VGND VGND VPWR VPWR sky130_fd_sc_hd__decap_3
XFILLER_29_326 VGND VGND VPWR VPWR sky130_fd_sc_hd__decap_3
XFILLER_84_421 VGND VGND VPWR VPWR sky130_fd_sc_hd__decap_3
XFILLER_29_337 VGND VGND VPWR VPWR sky130_fd_sc_hd__decap_3
XFILLER_57_668 VGND VGND VPWR VPWR sky130_fd_sc_hd__decap_3
X_5078_ _5581_/S _5069_/X _5077_/X _4467_/B _5666_/A VGND VGND VPWR VPWR _5078_/X
+ sky130_fd_sc_hd__a221o_2
XFILLER_57_679 VGND VGND VPWR VPWR sky130_fd_sc_hd__decap_3
XFILLER_72_616 VGND VGND VPWR VPWR sky130_fd_sc_hd__decap_3
XFILLER_44_318 VGND VGND VPWR VPWR sky130_fd_sc_hd__decap_3
XFILLER_71_148 VGND VGND VPWR VPWR sky130_fd_sc_hd__decap_3
XFILLER_52_340 VGND VGND VPWR VPWR sky130_fd_sc_hd__decap_3
XFILLER_80_660 VGND VGND VPWR VPWR sky130_fd_sc_hd__decap_3
XTAP_TAPCELL_ROW_80_1308 VGND VPWR sky130_fd_sc_hd__tapvpwrvgnd_1
XFILLER_25_576 VGND VGND VPWR VPWR sky130_fd_sc_hd__decap_3
XFILLER_40_513 VGND VGND VPWR VPWR sky130_fd_sc_hd__decap_3
XFILLER_13_727 VGND VGND VPWR VPWR sky130_fd_sc_hd__fill_1
XFILLER_80_693 VGND VGND VPWR VPWR sky130_fd_sc_hd__decap_3
XFILLER_9_709 VGND VGND VPWR VPWR sky130_fd_sc_hd__decap_3
XFILLER_12_237 VGND VGND VPWR VPWR sky130_fd_sc_hd__decap_3
XFILLER_40_568 VGND VGND VPWR VPWR sky130_fd_sc_hd__decap_3
XFILLER_12_259 VGND VGND VPWR VPWR sky130_fd_sc_hd__decap_3
XFILLER_100_53 VGND VGND VPWR VPWR sky130_fd_sc_hd__decap_3
XFILLER_8_219 VGND VGND VPWR VPWR sky130_fd_sc_hd__decap_3
XFILLER_114_3 VGND VGND VPWR VPWR sky130_fd_sc_hd__decap_3
XFILLER_109_51 VGND VGND VPWR VPWR sky130_fd_sc_hd__decap_3
XFILLER_118_191 VGND VGND VPWR VPWR sky130_fd_sc_hd__decap_3
XFILLER_69_33 VGND VGND VPWR VPWR sky130_fd_sc_hd__decap_3
XFILLER_79_204 VGND VGND VPWR VPWR sky130_fd_sc_hd__fill_1
XTAP_TAPCELL_ROW_91_1448 VGND VPWR sky130_fd_sc_hd__tapvpwrvgnd_1
XFILLER_121_323 VGND VGND VPWR VPWR sky130_fd_sc_hd__decap_3
XFILLER_0_620 VGND VGND VPWR VPWR sky130_fd_sc_hd__fill_1
XFILLER_121_334 VGND VGND VPWR VPWR sky130_fd_sc_hd__fill_2
XFILLER_79_259 VGND VGND VPWR VPWR sky130_fd_sc_hd__decap_3
XFILLER_0_653 VGND VGND VPWR VPWR sky130_fd_sc_hd__decap_3
XFILLER_121_367 VGND VGND VPWR VPWR sky130_fd_sc_hd__fill_1
XFILLER_94_218 VGND VGND VPWR VPWR sky130_fd_sc_hd__decap_3
XFILLER_48_624 VGND VGND VPWR VPWR sky130_fd_sc_hd__decap_3
XFILLER_102_581 VGND VGND VPWR VPWR sky130_fd_sc_hd__decap_3
XFILLER_102_592 VGND VGND VPWR VPWR sky130_fd_sc_hd__decap_3
XFILLER_48_657 VGND VGND VPWR VPWR sky130_fd_sc_hd__decap_3
XFILLER_85_76 VGND VGND VPWR VPWR sky130_fd_sc_hd__decap_3
XTAP_TAPCELL_ROW_18_505 VGND VPWR sky130_fd_sc_hd__tapvpwrvgnd_1
XFILLER_47_178 VGND VGND VPWR VPWR sky130_fd_sc_hd__fill_1
XFILLER_63_638 VGND VGND VPWR VPWR sky130_fd_sc_hd__decap_3
XFILLER_56_690 VGND VGND VPWR VPWR sky130_fd_sc_hd__decap_3
XFILLER_90_446 VGND VGND VPWR VPWR sky130_fd_sc_hd__decap_3
XTAP_TAPCELL_ROW_46_869 VGND VPWR sky130_fd_sc_hd__tapvpwrvgnd_1
XFILLER_43_340 VGND VGND VPWR VPWR sky130_fd_sc_hd__decap_3
XFILLER_71_671 VGND VGND VPWR VPWR sky130_fd_sc_hd__fill_1
XFILLER_16_576 VGND VGND VPWR VPWR sky130_fd_sc_hd__decap_3
XFILLER_71_682 VGND VGND VPWR VPWR sky130_fd_sc_hd__decap_3
XFILLER_16_598 VGND VGND VPWR VPWR sky130_fd_sc_hd__decap_3
XTAP_TAPCELL_ROW_100_1566 VGND VPWR sky130_fd_sc_hd__tapvpwrvgnd_1
XFILLER_8_731 VGND VGND VPWR VPWR sky130_fd_sc_hd__decap_3
XFILLER_79_6 VGND VGND VPWR VPWR sky130_fd_sc_hd__decap_3
XFILLER_11_281 VGND VGND VPWR VPWR sky130_fd_sc_hd__decap_3
XFILLER_7_241 VGND VGND VPWR VPWR sky130_fd_sc_hd__decap_3
XFILLER_11_292 VGND VGND VPWR VPWR sky130_fd_sc_hd__decap_3
XFILLER_117_629 VGND VGND VPWR VPWR sky130_fd_sc_hd__decap_3
XFILLER_116_106 VGND VGND VPWR VPWR sky130_fd_sc_hd__decap_3
X_3400_ _3449_/B VGND VGND VPWR VPWR _3421_/B sky130_fd_sc_hd__inv_2
XFILLER_7_296 VGND VGND VPWR VPWR sky130_fd_sc_hd__decap_3
X_4380_ _4380_/A _4380_/B VGND VGND VPWR VPWR _4381_/B sky130_fd_sc_hd__or2_2
X_3331_ _3331_/A _5667_/A _5135_/A1 VGND VGND VPWR VPWR _3528_/A sky130_fd_sc_hd__or3b_2
XFILLER_112_312 VGND VGND VPWR VPWR sky130_fd_sc_hd__decap_3
XFILLER_98_568 VGND VGND VPWR VPWR sky130_fd_sc_hd__decap_3
XFILLER_86_719 VGND VGND VPWR VPWR sky130_fd_sc_hd__decap_3
XFILLER_112_356 VGND VGND VPWR VPWR sky130_fd_sc_hd__decap_3
XFILLER_100_507 VGND VGND VPWR VPWR sky130_fd_sc_hd__decap_3
XFILLER_39_602 VGND VGND VPWR VPWR sky130_fd_sc_hd__decap_3
X_5001_ _5001_/A _5001_/B VGND VGND VPWR VPWR _6991_/D sky130_fd_sc_hd__nor2_2
XFILLER_112_378 VGND VGND VPWR VPWR sky130_fd_sc_hd__decap_3
XFILLER_66_410 VGND VGND VPWR VPWR sky130_fd_sc_hd__decap_3
XFILLER_78_281 VGND VGND VPWR VPWR sky130_fd_sc_hd__decap_3
XFILLER_39_635 VGND VGND VPWR VPWR sky130_fd_sc_hd__decap_3
XFILLER_39_668 VGND VGND VPWR VPWR sky130_fd_sc_hd__decap_3
XFILLER_93_240 VGND VGND VPWR VPWR sky130_fd_sc_hd__decap_3
XFILLER_39_679 VGND VGND VPWR VPWR sky130_fd_sc_hd__decap_3
XFILLER_54_616 VGND VGND VPWR VPWR sky130_fd_sc_hd__decap_3
XFILLER_38_178 VGND VGND VPWR VPWR sky130_fd_sc_hd__decap_3
XFILLER_26_318 VGND VGND VPWR VPWR sky130_fd_sc_hd__decap_3
XFILLER_93_273 VGND VGND VPWR VPWR sky130_fd_sc_hd__decap_3
X_6952_ clkload5/A _6952_/D VGND VGND VPWR VPWR _6952_/Q sky130_fd_sc_hd__dfxtp_2
XFILLER_93_284 VGND VGND VPWR VPWR sky130_fd_sc_hd__decap_3
XFILLER_38_189 VGND VGND VPWR VPWR sky130_fd_sc_hd__decap_3
XTAP_TAPCELL_ROW_66_1130 VGND VPWR sky130_fd_sc_hd__tapvpwrvgnd_1
XFILLER_34_340 VGND VGND VPWR VPWR sky130_fd_sc_hd__decap_3
X_6883_ _6942_/CLK _6883_/D VGND VGND VPWR VPWR _6883_/Q sky130_fd_sc_hd__dfxtp_2
XFILLER_62_660 VGND VGND VPWR VPWR sky130_fd_sc_hd__decap_3
XFILLER_22_502 VGND VGND VPWR VPWR sky130_fd_sc_hd__fill_1
XFILLER_62_693 VGND VGND VPWR VPWR sky130_fd_sc_hd__decap_3
XFILLER_10_719 VGND VGND VPWR VPWR sky130_fd_sc_hd__decap_3
XTAP_TAPCELL_ROW_118_1805 VGND VPWR sky130_fd_sc_hd__tapvpwrvgnd_1
X_4716_ _4910_/A _4664_/X _4695_/X _7008_/D _4997_/A1 VGND VGND VPWR VPWR _4716_/X
+ sky130_fd_sc_hd__a32o_2
XFILLER_108_607 VGND VGND VPWR VPWR sky130_fd_sc_hd__decap_3
X_4647_ _4813_/A _4827_/A _4647_/C _4787_/A VGND VGND VPWR VPWR _4647_/X sky130_fd_sc_hd__and4_2
XFILLER_30_27 VGND VGND VPWR VPWR sky130_fd_sc_hd__fill_1
XPHY_EDGE_ROW_15_Left_139 VGND VGND VPWR VPWR sky130_fd_sc_hd__decap_3
XFILLER_107_128 VGND VGND VPWR VPWR sky130_fd_sc_hd__decap_3
XFILLER_116_640 VGND VGND VPWR VPWR sky130_fd_sc_hd__decap_3
Xhold720 _6935_/Q VGND VGND VPWR VPWR _6935_/D sky130_fd_sc_hd__dlygate4sd3_1
X_7366_ _7395_/CLK _7366_/D _6646_/Y VGND VGND VPWR VPWR _7366_/Q sky130_fd_sc_hd__dfrtp_2
Xhold731 _6968_/Q VGND VGND VPWR VPWR _6968_/D sky130_fd_sc_hd__dlygate4sd3_1
XFILLER_116_651 VGND VGND VPWR VPWR sky130_fd_sc_hd__decap_3
XTAP_TAPCELL_ROW_77_1270 VGND VPWR sky130_fd_sc_hd__tapvpwrvgnd_1
Xhold742 _6771_/Q VGND VGND VPWR VPWR _6771_/D sky130_fd_sc_hd__dlygate4sd3_1
XFILLER_89_502 VGND VGND VPWR VPWR sky130_fd_sc_hd__fill_2
Xhold753 _6882_/Q VGND VGND VPWR VPWR _6882_/D sky130_fd_sc_hd__dlygate4sd3_1
XFILLER_122_109 VGND VGND VPWR VPWR sky130_fd_sc_hd__fill_2
X_6317_ _6633_/A VGND VGND VPWR VPWR _6317_/Y sky130_fd_sc_hd__inv_2
Xhold764 _6770_/Q VGND VGND VPWR VPWR _6770_/D sky130_fd_sc_hd__dlygate4sd3_1
XFILLER_116_684 VGND VGND VPWR VPWR sky130_fd_sc_hd__decap_3
Xhold775 _6973_/Q VGND VGND VPWR VPWR _6973_/D sky130_fd_sc_hd__dlygate4sd3_1
X_7297_ _7359_/CLK _7297_/D _6577_/Y VGND VGND VPWR VPWR _7297_/Q sky130_fd_sc_hd__dfrtp_2
XFILLER_115_172 VGND VGND VPWR VPWR sky130_fd_sc_hd__decap_3
Xhold786 _6941_/Q VGND VGND VPWR VPWR _6941_/D sky130_fd_sc_hd__dlygate4sd3_1
XFILLER_115_183 VGND VGND VPWR VPWR sky130_fd_sc_hd__decap_3
Xhold797 _6746_/Q VGND VGND VPWR VPWR _6746_/D sky130_fd_sc_hd__dlygate4sd3_1
XFILLER_89_579 VGND VGND VPWR VPWR sky130_fd_sc_hd__decap_3
XFILLER_39_69 VGND VGND VPWR VPWR sky130_fd_sc_hd__decap_3
XFILLER_69_281 VGND VGND VPWR VPWR sky130_fd_sc_hd__decap_3
XFILLER_29_145 VGND VGND VPWR VPWR sky130_fd_sc_hd__decap_3
XFILLER_57_465 VGND VGND VPWR VPWR sky130_fd_sc_hd__decap_3
XPHY_EDGE_ROW_24_Left_148 VGND VGND VPWR VPWR sky130_fd_sc_hd__decap_3
XFILLER_17_307 VGND VGND VPWR VPWR sky130_fd_sc_hd__decap_3
XFILLER_72_402 VGND VGND VPWR VPWR sky130_fd_sc_hd__fill_1
XFILLER_84_284 VGND VGND VPWR VPWR sky130_fd_sc_hd__decap_3
XFILLER_72_424 VGND VGND VPWR VPWR sky130_fd_sc_hd__decap_3
XFILLER_45_638 VGND VGND VPWR VPWR sky130_fd_sc_hd__decap_3
XFILLER_55_57 VGND VGND VPWR VPWR sky130_fd_sc_hd__decap_3
XFILLER_38_690 VGND VGND VPWR VPWR sky130_fd_sc_hd__decap_3
XFILLER_55_79 VGND VGND VPWR VPWR sky130_fd_sc_hd__decap_3
XFILLER_60_619 VGND VGND VPWR VPWR sky130_fd_sc_hd__decap_3
XFILLER_111_30 VGND VGND VPWR VPWR sky130_fd_sc_hd__decap_3
XTAP_TAPCELL_ROW_43_828 VGND VPWR sky130_fd_sc_hd__tapvpwrvgnd_1
XFILLER_53_671 VGND VGND VPWR VPWR sky130_fd_sc_hd__fill_1
XFILLER_25_362 VGND VGND VPWR VPWR sky130_fd_sc_hd__decap_3
XFILLER_13_502 VGND VGND VPWR VPWR sky130_fd_sc_hd__fill_2
XFILLER_53_682 VGND VGND VPWR VPWR sky130_fd_sc_hd__decap_3
XFILLER_71_12 VGND VGND VPWR VPWR sky130_fd_sc_hd__decap_3
XFILLER_111_63 VGND VGND VPWR VPWR sky130_fd_sc_hd__decap_3
XFILLER_13_557 VGND VGND VPWR VPWR sky130_fd_sc_hd__decap_3
XFILLER_40_354 VGND VGND VPWR VPWR sky130_fd_sc_hd__decap_3
XFILLER_13_579 VGND VGND VPWR VPWR sky130_fd_sc_hd__decap_3
XFILLER_40_365 VGND VGND VPWR VPWR sky130_fd_sc_hd__decap_3
XTAP_TAPCELL_ROW_23_563 VGND VPWR sky130_fd_sc_hd__tapvpwrvgnd_1
XPHY_EDGE_ROW_33_Left_157 VGND VGND VPWR VPWR sky130_fd_sc_hd__decap_3
XFILLER_5_712 VGND VGND VPWR VPWR sky130_fd_sc_hd__decap_3
XFILLER_4_200 VGND VGND VPWR VPWR sky130_fd_sc_hd__decap_3
XFILLER_4_233 VGND VGND VPWR VPWR sky130_fd_sc_hd__decap_3
XFILLER_107_662 VGND VGND VPWR VPWR sky130_fd_sc_hd__decap_3
XFILLER_107_673 VGND VGND VPWR VPWR sky130_fd_sc_hd__decap_3
XFILLER_122_610 VGND VGND VPWR VPWR sky130_fd_sc_hd__decap_3
XFILLER_106_161 VGND VGND VPWR VPWR sky130_fd_sc_hd__decap_3
XFILLER_20_93 VGND VGND VPWR VPWR sky130_fd_sc_hd__fill_1
XFILLER_122_643 VGND VGND VPWR VPWR sky130_fd_sc_hd__fill_1
XFILLER_122_654 VGND VGND VPWR VPWR sky130_fd_sc_hd__decap_3
XFILLER_121_131 VGND VGND VPWR VPWR sky130_fd_sc_hd__decap_3
XFILLER_95_505 VGND VGND VPWR VPWR sky130_fd_sc_hd__decap_3
XFILLER_68_719 VGND VGND VPWR VPWR sky130_fd_sc_hd__decap_3
XFILLER_96_53 VGND VGND VPWR VPWR sky130_fd_sc_hd__fill_1
XFILLER_67_207 VGND VGND VPWR VPWR sky130_fd_sc_hd__fill_1
XFILLER_122_687 VGND VGND VPWR VPWR sky130_fd_sc_hd__decap_3
XFILLER_95_527 VGND VGND VPWR VPWR sky130_fd_sc_hd__decap_3
XPHY_EDGE_ROW_42_Left_166 VGND VGND VPWR VPWR sky130_fd_sc_hd__decap_3
XFILLER_0_494 VGND VGND VPWR VPWR sky130_fd_sc_hd__decap_3
XFILLER_48_443 VGND VGND VPWR VPWR sky130_fd_sc_hd__decap_3
XFILLER_91_700 VGND VGND VPWR VPWR sky130_fd_sc_hd__decap_3
XFILLER_75_251 VGND VGND VPWR VPWR sky130_fd_sc_hd__fill_1
XFILLER_36_616 VGND VGND VPWR VPWR sky130_fd_sc_hd__decap_3
XFILLER_63_413 VGND VGND VPWR VPWR sky130_fd_sc_hd__decap_3
XFILLER_75_284 VGND VGND VPWR VPWR sky130_fd_sc_hd__decap_3
Xplace402 _4497_/S VGND VGND VPWR VPWR _4429_/A2 sky130_fd_sc_hd__buf_2
XFILLER_75_295 VGND VGND VPWR VPWR sky130_fd_sc_hd__decap_3
Xplace413 _4268_/B1 VGND VGND VPWR VPWR _4261_/A2 sky130_fd_sc_hd__buf_2
XFILLER_90_232 VGND VGND VPWR VPWR sky130_fd_sc_hd__decap_3
Xplace424 _3935_/S VGND VGND VPWR VPWR _3945_/S sky130_fd_sc_hd__buf_2
XFILLER_35_159 VGND VGND VPWR VPWR sky130_fd_sc_hd__decap_3
Xplace435 _3366_/X VGND VGND VPWR VPWR _4348_/A2 sky130_fd_sc_hd__buf_2
Xplace446 _4353_/A2 VGND VGND VPWR VPWR _4414_/A2 sky130_fd_sc_hd__buf_2
XFILLER_63_479 VGND VGND VPWR VPWR sky130_fd_sc_hd__decap_3
XFILLER_44_660 VGND VGND VPWR VPWR sky130_fd_sc_hd__decap_3
Xplace457 _3327_/B VGND VGND VPWR VPWR _3331_/A sky130_fd_sc_hd__buf_2
XFILLER_50_118 VGND VGND VPWR VPWR sky130_fd_sc_hd__decap_3
XFILLER_16_373 VGND VGND VPWR VPWR sky130_fd_sc_hd__decap_3
XFILLER_44_693 VGND VGND VPWR VPWR sky130_fd_sc_hd__decap_3
X_3880_ _3714_/X _3877_/X _3879_/X _3735_/X VGND VGND VPWR VPWR _3880_/X sky130_fd_sc_hd__a22o_2
XFILLER_31_332 VGND VGND VPWR VPWR sky130_fd_sc_hd__decap_3
XFILLER_31_343 VGND VGND VPWR VPWR sky130_fd_sc_hd__decap_3
XFILLER_31_365 VGND VGND VPWR VPWR sky130_fd_sc_hd__decap_3
XPHY_EDGE_ROW_51_Left_175 VGND VGND VPWR VPWR sky130_fd_sc_hd__decap_3
XTAP_TAPCELL_ROW_61_1060 VGND VPWR sky130_fd_sc_hd__tapvpwrvgnd_1
XFILLER_77_3 VGND VGND VPWR VPWR sky130_fd_sc_hd__decap_3
X_4501_ _4501_/A0 _7297_/Q _4505_/S VGND VGND VPWR VPWR _7329_/D sky130_fd_sc_hd__mux2_2
XFILLER_8_572 VGND VGND VPWR VPWR sky130_fd_sc_hd__decap_3
X_7220_ _7318_/CLK _7220_/D _6500_/Y VGND VGND VPWR VPWR _7220_/Q sky130_fd_sc_hd__dfrtp_2
X_4432_ _7079_/Q _4102_/B _4432_/B1 _4431_/X VGND VGND VPWR VPWR _4440_/A sky130_fd_sc_hd__o211ai_2
XTAP_TAPCELL_ROW_113_1735 VGND VPWR sky130_fd_sc_hd__tapvpwrvgnd_1
X_7151_ _7279_/CLK _7151_/D _6431_/Y VGND VGND VPWR VPWR _7151_/Q sky130_fd_sc_hd__dfrtp_2
X_4363_ _4619_/B VGND VGND VPWR VPWR _4369_/A sky130_fd_sc_hd__inv_2
XFILLER_113_632 VGND VGND VPWR VPWR sky130_fd_sc_hd__decap_3
X_3314_ _4467_/A _4467_/B VGND VGND VPWR VPWR _5647_/A sky130_fd_sc_hd__or2_2
X_7082_ _7404_/CLK _7082_/D _6362_/Y VGND VGND VPWR VPWR _7082_/Q sky130_fd_sc_hd__dfrtp_2
XFILLER_98_354 VGND VGND VPWR VPWR sky130_fd_sc_hd__decap_3
XFILLER_113_665 VGND VGND VPWR VPWR sky130_fd_sc_hd__decap_3
X_4294_ _4612_/A _4612_/B VGND VGND VPWR VPWR _5113_/A sky130_fd_sc_hd__xor2_2
XFILLER_98_365 VGND VGND VPWR VPWR sky130_fd_sc_hd__decap_3
XFILLER_113_676 VGND VGND VPWR VPWR sky130_fd_sc_hd__decap_3
XPHY_EDGE_ROW_60_Left_184 VGND VGND VPWR VPWR sky130_fd_sc_hd__decap_3
XFILLER_86_516 VGND VGND VPWR VPWR sky130_fd_sc_hd__fill_1
XFILLER_58_207 VGND VGND VPWR VPWR sky130_fd_sc_hd__decap_3
XFILLER_100_337 VGND VGND VPWR VPWR sky130_fd_sc_hd__decap_3
XFILLER_100_359 VGND VGND VPWR VPWR sky130_fd_sc_hd__decap_3
XFILLER_66_240 VGND VGND VPWR VPWR sky130_fd_sc_hd__decap_3
XFILLER_27_605 VGND VGND VPWR VPWR sky130_fd_sc_hd__decap_3
XFILLER_54_402 VGND VGND VPWR VPWR sky130_fd_sc_hd__fill_1
XFILLER_94_571 VGND VGND VPWR VPWR sky130_fd_sc_hd__decap_3
XFILLER_66_262 VGND VGND VPWR VPWR sky130_fd_sc_hd__decap_3
XFILLER_82_722 VGND VGND VPWR VPWR sky130_fd_sc_hd__decap_3
XFILLER_27_638 VGND VGND VPWR VPWR sky130_fd_sc_hd__decap_3
XFILLER_54_424 VGND VGND VPWR VPWR sky130_fd_sc_hd__decap_3
XFILLER_54_446 VGND VGND VPWR VPWR sky130_fd_sc_hd__decap_3
XFILLER_81_243 VGND VGND VPWR VPWR sky130_fd_sc_hd__decap_3
X_6935_ _7405_/CLK _6935_/D VGND VGND VPWR VPWR _6935_/Q sky130_fd_sc_hd__dfxtp_2
XFILLER_42_619 VGND VGND VPWR VPWR sky130_fd_sc_hd__decap_3
XFILLER_35_671 VGND VGND VPWR VPWR sky130_fd_sc_hd__fill_1
XFILLER_35_682 VGND VGND VPWR VPWR sky130_fd_sc_hd__decap_3
XFILLER_81_298 VGND VGND VPWR VPWR sky130_fd_sc_hd__decap_3
X_6866_ _7215_/CLK _6866_/D VGND VGND VPWR VPWR _6866_/Q sky130_fd_sc_hd__dfxtp_2
XFILLER_34_192 VGND VGND VPWR VPWR sky130_fd_sc_hd__decap_3
XFILLER_50_663 VGND VGND VPWR VPWR sky130_fd_sc_hd__decap_3
X_6797_ _7405_/CLK _6797_/D VGND VGND VPWR VPWR _6797_/Q sky130_fd_sc_hd__dfxtp_2
XFILLER_50_696 VGND VGND VPWR VPWR sky130_fd_sc_hd__decap_3
XTAP_TAPCELL_ROW_20_522 VGND VPWR sky130_fd_sc_hd__tapvpwrvgnd_1
XFILLER_41_37 VGND VGND VPWR VPWR sky130_fd_sc_hd__fill_1
XTAP_TAPCELL_ROW_20_533 VGND VPWR sky130_fd_sc_hd__tapvpwrvgnd_1
XFILLER_2_704 VGND VGND VPWR VPWR sky130_fd_sc_hd__decap_3
XFILLER_104_610 VGND VGND VPWR VPWR sky130_fd_sc_hd__decap_3
X_7349_ _7352_/CLK _7349_/D _6629_/Y VGND VGND VPWR VPWR _7349_/Q sky130_fd_sc_hd__dfrtp_2
XFILLER_1_203 VGND VGND VPWR VPWR sky130_fd_sc_hd__decap_3
XFILLER_89_332 VGND VGND VPWR VPWR sky130_fd_sc_hd__decap_3
XFILLER_1_225 VGND VGND VPWR VPWR sky130_fd_sc_hd__decap_3
Xhold583 _6944_/Q VGND VGND VPWR VPWR _6944_/D sky130_fd_sc_hd__dlygate4sd3_1
XFILLER_104_643 VGND VGND VPWR VPWR sky130_fd_sc_hd__fill_1
XFILLER_104_654 VGND VGND VPWR VPWR sky130_fd_sc_hd__decap_3
Xhold594 _6853_/Q VGND VGND VPWR VPWR _6853_/D sky130_fd_sc_hd__dlygate4sd3_1
XFILLER_89_354 VGND VGND VPWR VPWR sky130_fd_sc_hd__decap_3
XFILLER_77_505 VGND VGND VPWR VPWR sky130_fd_sc_hd__decap_3
XFILLER_89_376 VGND VGND VPWR VPWR sky130_fd_sc_hd__decap_3
XFILLER_49_207 VGND VGND VPWR VPWR sky130_fd_sc_hd__decap_3
XFILLER_103_153 VGND VGND VPWR VPWR sky130_fd_sc_hd__decap_3
XFILLER_77_527 VGND VGND VPWR VPWR sky130_fd_sc_hd__decap_3
XFILLER_104_687 VGND VGND VPWR VPWR sky130_fd_sc_hd__decap_3
XFILLER_103_175 VGND VGND VPWR VPWR sky130_fd_sc_hd__decap_3
XFILLER_66_12 VGND VGND VPWR VPWR sky130_fd_sc_hd__decap_3
XFILLER_73_700 VGND VGND VPWR VPWR sky130_fd_sc_hd__decap_3
XFILLER_18_616 VGND VGND VPWR VPWR sky130_fd_sc_hd__decap_3
XFILLER_45_402 VGND VGND VPWR VPWR sky130_fd_sc_hd__decap_3
XFILLER_85_582 VGND VGND VPWR VPWR sky130_fd_sc_hd__decap_3
XFILLER_72_210 VGND VGND VPWR VPWR sky130_fd_sc_hd__decap_3
XFILLER_45_424 VGND VGND VPWR VPWR sky130_fd_sc_hd__decap_3
XTAP_TAPCELL_ROW_28_633 VGND VPWR sky130_fd_sc_hd__tapvpwrvgnd_1
XFILLER_72_221 VGND VGND VPWR VPWR sky130_fd_sc_hd__decap_3
XFILLER_122_62 VGND VGND VPWR VPWR sky130_fd_sc_hd__decap_3
XFILLER_33_608 VGND VGND VPWR VPWR sky130_fd_sc_hd__decap_3
XFILLER_26_660 VGND VGND VPWR VPWR sky130_fd_sc_hd__decap_3
XTAP_TAPCELL_ROW_56_997 VGND VPWR sky130_fd_sc_hd__tapvpwrvgnd_1
XFILLER_82_44 VGND VGND VPWR VPWR sky130_fd_sc_hd__fill_1
XFILLER_82_55 VGND VGND VPWR VPWR sky130_fd_sc_hd__decap_3
XFILLER_26_693 VGND VGND VPWR VPWR sky130_fd_sc_hd__decap_3
XFILLER_82_77 VGND VGND VPWR VPWR sky130_fd_sc_hd__decap_3
XFILLER_13_321 VGND VGND VPWR VPWR sky130_fd_sc_hd__decap_3
XFILLER_82_88 VGND VGND VPWR VPWR sky130_fd_sc_hd__decap_3
XFILLER_41_641 VGND VGND VPWR VPWR sky130_fd_sc_hd__decap_3
XFILLER_13_365 VGND VGND VPWR VPWR sky130_fd_sc_hd__decap_3
XFILLER_41_685 VGND VGND VPWR VPWR sky130_fd_sc_hd__decap_3
XFILLER_15_93 VGND VGND VPWR VPWR sky130_fd_sc_hd__fill_2
XFILLER_5_531 VGND VGND VPWR VPWR sky130_fd_sc_hd__decap_3
XFILLER_5_564 VGND VGND VPWR VPWR sky130_fd_sc_hd__decap_3
XFILLER_5_597 VGND VGND VPWR VPWR sky130_fd_sc_hd__decap_3
XFILLER_107_481 VGND VGND VPWR VPWR sky130_fd_sc_hd__fill_2
XFILLER_68_505 VGND VGND VPWR VPWR sky130_fd_sc_hd__decap_3
XFILLER_122_462 VGND VGND VPWR VPWR sky130_fd_sc_hd__decap_3
XFILLER_110_613 VGND VGND VPWR VPWR sky130_fd_sc_hd__decap_3
XFILLER_95_313 VGND VGND VPWR VPWR sky130_fd_sc_hd__decap_3
XFILLER_95_335 VGND VGND VPWR VPWR sky130_fd_sc_hd__fill_1
XFILLER_68_549 VGND VGND VPWR VPWR sky130_fd_sc_hd__fill_2
XFILLER_122_495 VGND VGND VPWR VPWR sky130_fd_sc_hd__decap_3
XFILLER_110_657 VGND VGND VPWR VPWR sky130_fd_sc_hd__decap_3
XFILLER_95_368 VGND VGND VPWR VPWR sky130_fd_sc_hd__decap_3
XFILLER_83_508 VGND VGND VPWR VPWR sky130_fd_sc_hd__decap_3
XFILLER_48_251 VGND VGND VPWR VPWR sky130_fd_sc_hd__fill_1
XFILLER_64_722 VGND VGND VPWR VPWR sky130_fd_sc_hd__decap_3
XFILLER_36_424 VGND VGND VPWR VPWR sky130_fd_sc_hd__decap_3
XFILLER_48_284 VGND VGND VPWR VPWR sky130_fd_sc_hd__decap_3
XFILLER_24_619 VGND VGND VPWR VPWR sky130_fd_sc_hd__decap_3
X_4981_ _6992_/Q _5001_/A VGND VGND VPWR VPWR _6992_/D sky130_fd_sc_hd__xor2_2
XFILLER_51_405 VGND VGND VPWR VPWR sky130_fd_sc_hd__decap_3
XFILLER_91_585 VGND VGND VPWR VPWR sky130_fd_sc_hd__decap_3
XFILLER_17_671 VGND VGND VPWR VPWR sky130_fd_sc_hd__fill_1
XFILLER_17_682 VGND VGND VPWR VPWR sky130_fd_sc_hd__decap_3
X_6720_ clkload6/A _6720_/D VGND VGND VPWR VPWR _6720_/Q sky130_fd_sc_hd__dfxtp_2
XFILLER_51_449 VGND VGND VPWR VPWR sky130_fd_sc_hd__decap_3
XFILLER_16_170 VGND VGND VPWR VPWR sky130_fd_sc_hd__decap_3
Xplace276 _3665_/X VGND VGND VPWR VPWR _3891_/B1 sky130_fd_sc_hd__buf_2
XFILLER_16_181 VGND VGND VPWR VPWR sky130_fd_sc_hd__decap_3
Xplace287 _3886_/A2 VGND VGND VPWR VPWR _3906_/A2 sky130_fd_sc_hd__buf_2
Xclkbuf_leaf_43_clk clkbuf_leaf_1_clk/A VGND VGND VPWR VPWR clkload7/A sky130_fd_sc_hd__clkbuf_16
Xplace298 _3889_/A2 VGND VGND VPWR VPWR _3926_/B1 sky130_fd_sc_hd__buf_2
X_6651_ _6651_/A VGND VGND VPWR VPWR _6651_/Y sky130_fd_sc_hd__inv_2
XFILLER_32_663 VGND VGND VPWR VPWR sky130_fd_sc_hd__decap_3
X_3863_ _6697_/Q _3917_/A2 _3925_/B1 _6875_/Q _3862_/X VGND VGND VPWR VPWR _3863_/X
+ sky130_fd_sc_hd__a221o_2
XFILLER_32_696 VGND VGND VPWR VPWR sky130_fd_sc_hd__decap_3
X_5602_ _5602_/A _5634_/B VGND VGND VPWR VPWR _7026_/D sky130_fd_sc_hd__and2_2
XFILLER_31_173 VGND VGND VPWR VPWR sky130_fd_sc_hd__decap_3
X_6582_ _6616_/A VGND VGND VPWR VPWR _6582_/Y sky130_fd_sc_hd__inv_2
X_3794_ _6774_/Q _3888_/A2 _3891_/A2 _6762_/Q _3793_/X VGND VGND VPWR VPWR _3794_/X
+ sky130_fd_sc_hd__a221o_2
XFILLER_118_713 VGND VGND VPWR VPWR sky130_fd_sc_hd__decap_3
XFILLER_11_29 VGND VGND VPWR VPWR sky130_fd_sc_hd__decap_3
XFILLER_8_391 VGND VGND VPWR VPWR sky130_fd_sc_hd__fill_1
X_7203_ _7395_/CLK _7203_/D _6483_/Y VGND VGND VPWR VPWR _7203_/Q sky130_fd_sc_hd__dfrtp_2
X_4415_ _7400_/Q _4419_/B1 _4434_/B1 _7144_/Q _4414_/X VGND VGND VPWR VPWR _4415_/X
+ sky130_fd_sc_hd__a221o_2
XFILLER_99_641 VGND VGND VPWR VPWR sky130_fd_sc_hd__decap_3
X_7134_ _7360_/CLK _7134_/D _6414_/Y VGND VGND VPWR VPWR _7134_/Q sky130_fd_sc_hd__dfrtp_2
X_4346_ _7321_/Q _3975_/S _4346_/B1 _7353_/Q VGND VGND VPWR VPWR _4346_/X sky130_fd_sc_hd__a22o_2
XFILLER_98_151 VGND VGND VPWR VPWR sky130_fd_sc_hd__decap_3
XFILLER_59_505 VGND VGND VPWR VPWR sky130_fd_sc_hd__decap_3
XFILLER_99_685 VGND VGND VPWR VPWR sky130_fd_sc_hd__decap_3
XFILLER_86_302 VGND VGND VPWR VPWR sky130_fd_sc_hd__decap_3
XTAP_TAPCELL_ROW_6_339 VGND VPWR sky130_fd_sc_hd__tapvpwrvgnd_1
X_7065_ _7392_/CLK _7065_/D _6345_/Y VGND VGND VPWR VPWR _7065_/Q sky130_fd_sc_hd__dfrtp_2
XFILLER_101_635 VGND VGND VPWR VPWR sky130_fd_sc_hd__decap_3
X_4277_ _5003_/A _4277_/B VGND VGND VPWR VPWR _4277_/Y sky130_fd_sc_hd__nor2_2
XFILLER_86_368 VGND VGND VPWR VPWR sky130_fd_sc_hd__decap_3
XFILLER_101_668 VGND VGND VPWR VPWR sky130_fd_sc_hd__decap_3
XFILLER_39_240 VGND VGND VPWR VPWR sky130_fd_sc_hd__decap_3
XFILLER_101_679 VGND VGND VPWR VPWR sky130_fd_sc_hd__decap_3
XFILLER_100_156 VGND VGND VPWR VPWR sky130_fd_sc_hd__decap_3
XFILLER_55_700 VGND VGND VPWR VPWR sky130_fd_sc_hd__decap_3
XFILLER_27_402 VGND VGND VPWR VPWR sky130_fd_sc_hd__decap_3
XFILLER_39_295 VGND VGND VPWR VPWR sky130_fd_sc_hd__decap_3
XFILLER_54_232 VGND VGND VPWR VPWR sky130_fd_sc_hd__decap_3
XFILLER_54_243 VGND VGND VPWR VPWR sky130_fd_sc_hd__decap_3
XFILLER_36_59 VGND VGND VPWR VPWR sky130_fd_sc_hd__decap_3
XFILLER_27_468 VGND VGND VPWR VPWR sky130_fd_sc_hd__decap_3
XFILLER_82_574 VGND VGND VPWR VPWR sky130_fd_sc_hd__decap_3
XFILLER_42_405 VGND VGND VPWR VPWR sky130_fd_sc_hd__decap_3
XFILLER_70_725 VGND VGND VPWR VPWR sky130_fd_sc_hd__decap_3
XFILLER_42_427 VGND VGND VPWR VPWR sky130_fd_sc_hd__decap_3
XFILLER_54_287 VGND VGND VPWR VPWR sky130_fd_sc_hd__decap_3
X_6918_ _7378_/CLK _6918_/D VGND VGND VPWR VPWR _6918_/Q sky130_fd_sc_hd__dfxtp_2
XTAP_TAPCELL_ROW_53_956 VGND VPWR sky130_fd_sc_hd__tapvpwrvgnd_1
Xclkbuf_leaf_34_clk clkbuf_leaf_2_clk/A VGND VGND VPWR VPWR _7318_/CLK sky130_fd_sc_hd__clkbuf_16
XFILLER_23_641 VGND VGND VPWR VPWR sky130_fd_sc_hd__decap_3
X_6849_ _6926_/CLK _6849_/D VGND VGND VPWR VPWR _6849_/Q sky130_fd_sc_hd__dfxtp_2
XFILLER_23_685 VGND VGND VPWR VPWR sky130_fd_sc_hd__decap_3
XTAP_TAPCELL_ROW_33_691 VGND VPWR sky130_fd_sc_hd__tapvpwrvgnd_1
XFILLER_22_195 VGND VGND VPWR VPWR sky130_fd_sc_hd__fill_1
XFILLER_10_357 VGND VGND VPWR VPWR sky130_fd_sc_hd__fill_2
XFILLER_10_368 VGND VGND VPWR VPWR sky130_fd_sc_hd__fill_2
XFILLER_109_724 VGND VGND VPWR VPWR sky130_fd_sc_hd__decap_3
XFILLER_10_379 VGND VGND VPWR VPWR sky130_fd_sc_hd__fill_2
XFILLER_108_223 VGND VGND VPWR VPWR sky130_fd_sc_hd__decap_3
XPHY_EDGE_ROW_107_Left_231 VGND VGND VPWR VPWR sky130_fd_sc_hd__decap_3
XFILLER_2_501 VGND VGND VPWR VPWR sky130_fd_sc_hd__decap_3
XFILLER_2_545 VGND VGND VPWR VPWR sky130_fd_sc_hd__decap_3
XFILLER_117_51 VGND VGND VPWR VPWR sky130_fd_sc_hd__decap_3
XFILLER_123_259 VGND VGND VPWR VPWR sky130_fd_sc_hd__fill_2
XFILLER_104_451 VGND VGND VPWR VPWR sky130_fd_sc_hd__decap_3
XFILLER_77_302 VGND VGND VPWR VPWR sky130_fd_sc_hd__decap_3
XFILLER_2_578 VGND VGND VPWR VPWR sky130_fd_sc_hd__decap_3
XFILLER_117_84 VGND VGND VPWR VPWR sky130_fd_sc_hd__decap_3
XFILLER_2_589 VGND VGND VPWR VPWR sky130_fd_sc_hd__decap_3
XFILLER_77_335 VGND VGND VPWR VPWR sky130_fd_sc_hd__fill_1
XFILLER_77_346 VGND VGND VPWR VPWR sky130_fd_sc_hd__decap_3
XTAP_TAPCELL_ROW_88_1409 VGND VPWR sky130_fd_sc_hd__tapvpwrvgnd_1
XFILLER_77_368 VGND VGND VPWR VPWR sky130_fd_sc_hd__decap_3
XFILLER_92_316 VGND VGND VPWR VPWR sky130_fd_sc_hd__decap_3
XFILLER_46_722 VGND VGND VPWR VPWR sky130_fd_sc_hd__decap_3
XFILLER_18_424 VGND VGND VPWR VPWR sky130_fd_sc_hd__decap_3
XPHY_EDGE_ROW_116_Left_240 VGND VGND VPWR VPWR sky130_fd_sc_hd__decap_3
XFILLER_92_349 VGND VGND VPWR VPWR sky130_fd_sc_hd__decap_3
XFILLER_100_690 VGND VGND VPWR VPWR sky130_fd_sc_hd__decap_3
Xhold1080 _7155_/Q VGND VGND VPWR VPWR _5352_/A0 sky130_fd_sc_hd__dlygate4sd3_1
Xhold1091 _7291_/Q VGND VGND VPWR VPWR _4579_/A sky130_fd_sc_hd__dlygate4sd3_1
XFILLER_18_457 VGND VGND VPWR VPWR sky130_fd_sc_hd__fill_2
XFILLER_61_703 VGND VGND VPWR VPWR sky130_fd_sc_hd__decap_3
XFILLER_45_265 VGND VGND VPWR VPWR sky130_fd_sc_hd__decap_3
XFILLER_33_405 VGND VGND VPWR VPWR sky130_fd_sc_hd__decap_3
XFILLER_73_596 VGND VGND VPWR VPWR sky130_fd_sc_hd__decap_3
XFILLER_33_438 VGND VGND VPWR VPWR sky130_fd_sc_hd__decap_3
XFILLER_33_449 VGND VGND VPWR VPWR sky130_fd_sc_hd__fill_1
Xclkbuf_leaf_25_clk clkbuf_3_6__f_clk/X VGND VGND VPWR VPWR _7359_/CLK sky130_fd_sc_hd__clkbuf_16
XFILLER_14_663 VGND VGND VPWR VPWR sky130_fd_sc_hd__decap_3
XFILLER_41_471 VGND VGND VPWR VPWR sky130_fd_sc_hd__decap_3
XFILLER_14_696 VGND VGND VPWR VPWR sky130_fd_sc_hd__decap_3
XFILLER_9_133 VGND VGND VPWR VPWR sky130_fd_sc_hd__fill_1
XFILLER_13_195 VGND VGND VPWR VPWR sky130_fd_sc_hd__fill_2
XTAP_TAPCELL_ROW_99_1549 VGND VPWR sky130_fd_sc_hd__tapvpwrvgnd_1
XFILLER_42_91 VGND VGND VPWR VPWR sky130_fd_sc_hd__fill_2
XFILLER_9_188 VGND VGND VPWR VPWR sky130_fd_sc_hd__decap_3
XFILLER_61_6 VGND VGND VPWR VPWR sky130_fd_sc_hd__fill_2
XFILLER_115_727 VGND VGND VPWR VPWR sky130_fd_sc_hd__fill_1
XFILLER_114_215 VGND VGND VPWR VPWR sky130_fd_sc_hd__decap_3
X_4200_ _4200_/A _4381_/A VGND VGND VPWR VPWR _4200_/X sky130_fd_sc_hd__or2_2
XFILLER_114_259 VGND VGND VPWR VPWR sky130_fd_sc_hd__decap_3
XFILLER_96_622 VGND VGND VPWR VPWR sky130_fd_sc_hd__decap_3
X_4131_ _7267_/Q _4437_/A2 _4128_/X _4130_/X VGND VGND VPWR VPWR _4131_/X sky130_fd_sc_hd__a211o_2
XFILLER_110_421 VGND VGND VPWR VPWR sky130_fd_sc_hd__decap_3
XTAP_TAPCELL_ROW_3_309 VGND VPWR sky130_fd_sc_hd__tapvpwrvgnd_1
XFILLER_95_132 VGND VGND VPWR VPWR sky130_fd_sc_hd__decap_3
XFILLER_3_74 VGND VGND VPWR VPWR sky130_fd_sc_hd__fill_1
XFILLER_96_666 VGND VGND VPWR VPWR sky130_fd_sc_hd__decap_3
X_4062_ _7026_/Q _4431_/A2 _3935_/S _7212_/Q _4061_/X VGND VGND VPWR VPWR _4062_/X
+ sky130_fd_sc_hd__a221o_2
XFILLER_56_519 VGND VGND VPWR VPWR sky130_fd_sc_hd__decap_3
XFILLER_96_699 VGND VGND VPWR VPWR sky130_fd_sc_hd__fill_1
XFILLER_37_700 VGND VGND VPWR VPWR sky130_fd_sc_hd__decap_3
XFILLER_36_221 VGND VGND VPWR VPWR sky130_fd_sc_hd__decap_3
XFILLER_36_243 VGND VGND VPWR VPWR sky130_fd_sc_hd__decap_3
XTAP_TAPCELL_ROW_108_1667 VGND VPWR sky130_fd_sc_hd__tapvpwrvgnd_1
XFILLER_52_725 VGND VGND VPWR VPWR sky130_fd_sc_hd__decap_3
XFILLER_51_202 VGND VGND VPWR VPWR sky130_fd_sc_hd__decap_3
XFILLER_24_427 VGND VGND VPWR VPWR sky130_fd_sc_hd__decap_3
XFILLER_36_298 VGND VGND VPWR VPWR sky130_fd_sc_hd__fill_2
XFILLER_91_393 VGND VGND VPWR VPWR sky130_fd_sc_hd__decap_3
X_4964_ _4910_/A _4961_/X _6994_/D _4997_/A1 VGND VGND VPWR VPWR _4964_/X sky130_fd_sc_hd__a22o_2
XTAP_TAPCELL_ROW_121_1834 VGND VPWR sky130_fd_sc_hd__tapvpwrvgnd_1
Xclkbuf_leaf_16_clk clkload2/A VGND VGND VPWR VPWR _7372_/CLK sky130_fd_sc_hd__clkbuf_16
XTAP_TAPCELL_ROW_121_1845 VGND VPWR sky130_fd_sc_hd__tapvpwrvgnd_1
XTAP_TAPCELL_ROW_50_915 VGND VPWR sky130_fd_sc_hd__tapvpwrvgnd_1
X_6703_ _7325_/CLK _6703_/D VGND VGND VPWR VPWR _6703_/Q sky130_fd_sc_hd__dfxtp_2
X_3915_ _7378_/Q _3914_/X _3991_/A VGND VGND VPWR VPWR _7378_/D sky130_fd_sc_hd__mux2_2
XFILLER_51_279 VGND VGND VPWR VPWR sky130_fd_sc_hd__fill_1
X_4895_ _6997_/Q _4690_/B _4909_/B VGND VGND VPWR VPWR _4896_/B sky130_fd_sc_hd__a21o_2
XFILLER_32_471 VGND VGND VPWR VPWR sky130_fd_sc_hd__decap_3
XFILLER_20_622 VGND VGND VPWR VPWR sky130_fd_sc_hd__decap_3
X_3846_ _6964_/Q _3851_/A2 _3651_/Y _6952_/Q VGND VGND VPWR VPWR _3846_/X sky130_fd_sc_hd__a22o_2
X_6634_ _6637_/A VGND VGND VPWR VPWR _6634_/Y sky130_fd_sc_hd__inv_2
XFILLER_20_666 VGND VGND VPWR VPWR sky130_fd_sc_hd__decap_3
XFILLER_118_510 VGND VGND VPWR VPWR sky130_fd_sc_hd__decap_3
XTAP_TAPCELL_ROW_30_661 VGND VPWR sky130_fd_sc_hd__tapvpwrvgnd_1
X_3777_ _6972_/Q _5660_/B _3665_/X _6722_/Q _3776_/X VGND VGND VPWR VPWR _3777_/X
+ sky130_fd_sc_hd__a221o_2
X_6565_ _6566_/A VGND VGND VPWR VPWR _6565_/Y sky130_fd_sc_hd__inv_2
XFILLER_20_699 VGND VGND VPWR VPWR sky130_fd_sc_hd__fill_1
XFILLER_118_554 VGND VGND VPWR VPWR sky130_fd_sc_hd__decap_3
X_6496_ _6504_/A VGND VGND VPWR VPWR _6496_/Y sky130_fd_sc_hd__inv_2
XFILLER_106_716 VGND VGND VPWR VPWR sky130_fd_sc_hd__decap_3
XFILLER_118_587 VGND VGND VPWR VPWR sky130_fd_sc_hd__fill_1
XFILLER_105_204 VGND VGND VPWR VPWR sky130_fd_sc_hd__fill_2
XFILLER_118_598 VGND VGND VPWR VPWR sky130_fd_sc_hd__decap_3
XFILLER_105_215 VGND VGND VPWR VPWR sky130_fd_sc_hd__fill_2
XFILLER_105_237 VGND VGND VPWR VPWR sky130_fd_sc_hd__fill_1
Xoutput463 _5662_/B VGND VGND VPWR VPWR alu_result_out[11] sky130_fd_sc_hd__clkdlybuf4s25_1
Xoutput474 _5656_/B VGND VGND VPWR VPWR alu_result_out[21] sky130_fd_sc_hd__clkdlybuf4s25_1
XFILLER_87_600 VGND VGND VPWR VPWR sky130_fd_sc_hd__decap_3
Xoutput485 _5654_/Y VGND VGND VPWR VPWR alu_result_out[31] sky130_fd_sc_hd__clkdlybuf4s25_1
Xoutput496 _3525_/A VGND VGND VPWR VPWR instruction_out[13] sky130_fd_sc_hd__clkdlybuf4s25_1
XFILLER_101_410 VGND VGND VPWR VPWR sky130_fd_sc_hd__decap_3
X_4329_ _4362_/C _4362_/A _4362_/B VGND VGND VPWR VPWR _4330_/B sky130_fd_sc_hd__and3b_2
X_7117_ _7406_/CLK _7117_/D _6397_/Y VGND VGND VPWR VPWR _7117_/Q sky130_fd_sc_hd__dfrtp_2
XFILLER_87_644 VGND VGND VPWR VPWR sky130_fd_sc_hd__decap_3
XFILLER_113_281 VGND VGND VPWR VPWR sky130_fd_sc_hd__decap_3
XFILLER_86_132 VGND VGND VPWR VPWR sky130_fd_sc_hd__decap_3
XFILLER_59_346 VGND VGND VPWR VPWR sky130_fd_sc_hd__decap_3
XFILLER_101_443 VGND VGND VPWR VPWR sky130_fd_sc_hd__decap_3
XFILLER_47_508 VGND VGND VPWR VPWR sky130_fd_sc_hd__fill_2
X_7048_ _7395_/CLK _7048_/D _6328_/Y VGND VGND VPWR VPWR _7048_/Q sky130_fd_sc_hd__dfrtp_2
XFILLER_86_154 VGND VGND VPWR VPWR sky130_fd_sc_hd__decap_3
XFILLER_87_688 VGND VGND VPWR VPWR sky130_fd_sc_hd__decap_3
XFILLER_74_305 VGND VGND VPWR VPWR sky130_fd_sc_hd__decap_3
XPHY_EDGE_ROW_114_Right_114 VGND VGND VPWR VPWR sky130_fd_sc_hd__decap_3
XFILLER_86_187 VGND VGND VPWR VPWR sky130_fd_sc_hd__decap_3
XFILLER_28_722 VGND VGND VPWR VPWR sky130_fd_sc_hd__decap_3
XFILLER_27_221 VGND VGND VPWR VPWR sky130_fd_sc_hd__decap_3
XFILLER_43_703 VGND VGND VPWR VPWR sky130_fd_sc_hd__decap_3
XFILLER_27_254 VGND VGND VPWR VPWR sky130_fd_sc_hd__decap_3
XTAP_TAPCELL_ROW_38_761 VGND VPWR sky130_fd_sc_hd__tapvpwrvgnd_1
XFILLER_15_405 VGND VGND VPWR VPWR sky130_fd_sc_hd__decap_3
XFILLER_15_416 VGND VGND VPWR VPWR sky130_fd_sc_hd__decap_3
XFILLER_82_371 VGND VGND VPWR VPWR sky130_fd_sc_hd__fill_1
XFILLER_82_382 VGND VGND VPWR VPWR sky130_fd_sc_hd__decap_3
XFILLER_27_287 VGND VGND VPWR VPWR sky130_fd_sc_hd__decap_3
XFILLER_70_533 VGND VGND VPWR VPWR sky130_fd_sc_hd__decap_3
XFILLER_42_224 VGND VGND VPWR VPWR sky130_fd_sc_hd__decap_3
XFILLER_15_449 VGND VGND VPWR VPWR sky130_fd_sc_hd__fill_2
XFILLER_70_566 VGND VGND VPWR VPWR sky130_fd_sc_hd__decap_3
XFILLER_11_600 VGND VGND VPWR VPWR sky130_fd_sc_hd__decap_3
XFILLER_11_644 VGND VGND VPWR VPWR sky130_fd_sc_hd__decap_3
XFILLER_7_615 VGND VGND VPWR VPWR sky130_fd_sc_hd__fill_1
XFILLER_7_626 VGND VGND VPWR VPWR sky130_fd_sc_hd__decap_3
XFILLER_11_688 VGND VGND VPWR VPWR sky130_fd_sc_hd__decap_3
Xwire568 _4467_/Y VGND VGND VPWR VPWR _5595_/B sky130_fd_sc_hd__clkbuf_4
XFILLER_7_659 VGND VGND VPWR VPWR sky130_fd_sc_hd__decap_3
XFILLER_6_136 VGND VGND VPWR VPWR sky130_fd_sc_hd__decap_3
XFILLER_109_543 VGND VGND VPWR VPWR sky130_fd_sc_hd__decap_3
XFILLER_12_61 VGND VGND VPWR VPWR sky130_fd_sc_hd__fill_1
XFILLER_109_576 VGND VGND VPWR VPWR sky130_fd_sc_hd__decap_3
XFILLER_88_54 VGND VGND VPWR VPWR sky130_fd_sc_hd__decap_3
XFILLER_112_719 VGND VGND VPWR VPWR sky130_fd_sc_hd__decap_3
XFILLER_97_419 VGND VGND VPWR VPWR sky130_fd_sc_hd__decap_3
XFILLER_111_218 VGND VGND VPWR VPWR sky130_fd_sc_hd__decap_3
XFILLER_78_622 VGND VGND VPWR VPWR sky130_fd_sc_hd__decap_3
XFILLER_78_666 VGND VGND VPWR VPWR sky130_fd_sc_hd__decap_3
XFILLER_93_603 VGND VGND VPWR VPWR sky130_fd_sc_hd__decap_3
XFILLER_77_165 VGND VGND VPWR VPWR sky130_fd_sc_hd__decap_3
XFILLER_65_305 VGND VGND VPWR VPWR sky130_fd_sc_hd__decap_3
XFILLER_19_700 VGND VGND VPWR VPWR sky130_fd_sc_hd__decap_3
XFILLER_78_699 VGND VGND VPWR VPWR sky130_fd_sc_hd__fill_1
XFILLER_77_187 VGND VGND VPWR VPWR sky130_fd_sc_hd__decap_3
XFILLER_93_647 VGND VGND VPWR VPWR sky130_fd_sc_hd__decap_3
XFILLER_18_232 VGND VGND VPWR VPWR sky130_fd_sc_hd__decap_3
XFILLER_34_725 VGND VGND VPWR VPWR sky130_fd_sc_hd__decap_3
XFILLER_61_511 VGND VGND VPWR VPWR sky130_fd_sc_hd__decap_3
XFILLER_46_596 VGND VGND VPWR VPWR sky130_fd_sc_hd__decap_3
XFILLER_73_393 VGND VGND VPWR VPWR sky130_fd_sc_hd__decap_3
XTAP_TAPCELL_ROW_16_477 VGND VPWR sky130_fd_sc_hd__tapvpwrvgnd_1
X_3700_ _6939_/Q _3898_/A2 _3759_/A2 _6803_/Q _3699_/X VGND VGND VPWR VPWR _3700_/X
+ sky130_fd_sc_hd__a221o_2
X_4680_ _4680_/A _5015_/B VGND VGND VPWR VPWR _5009_/A sky130_fd_sc_hd__nor2_2
XFILLER_41_290 VGND VGND VPWR VPWR sky130_fd_sc_hd__fill_2
X_3631_ _3630_/A _3630_/B _5146_/B1 VGND VGND VPWR VPWR _3631_/Y sky130_fd_sc_hd__o21ai_2
X_6350_ _6350_/A VGND VGND VPWR VPWR _6350_/Y sky130_fd_sc_hd__inv_2
X_3562_ _3562_/A _3562_/B _3561_/X VGND VGND VPWR VPWR _5362_/C sky130_fd_sc_hd__or3b_2
XTAP_TAPCELL_ROW_58_1021 VGND VPWR sky130_fd_sc_hd__tapvpwrvgnd_1
XFILLER_6_681 VGND VGND VPWR VPWR sky130_fd_sc_hd__decap_3
X_6281_ _6462_/A VGND VGND VPWR VPWR _6281_/Y sky130_fd_sc_hd__inv_2
XFILLER_115_535 VGND VGND VPWR VPWR sky130_fd_sc_hd__decap_3
X_3493_ _7087_/Q _3417_/X _3407_/X _7119_/Q VGND VGND VPWR VPWR _3493_/X sky130_fd_sc_hd__a22o_2
X_5232_ _5232_/A0 _4716_/X _5258_/S VGND VGND VPWR VPWR _7214_/D sky130_fd_sc_hd__mux2_2
XFILLER_115_579 VGND VGND VPWR VPWR sky130_fd_sc_hd__decap_3
Xclkbuf_leaf_5_clk clkload0/A VGND VGND VPWR VPWR clkload9/A sky130_fd_sc_hd__clkbuf_16
XFILLER_88_419 VGND VGND VPWR VPWR sky130_fd_sc_hd__fill_1
XFILLER_102_207 VGND VGND VPWR VPWR sky130_fd_sc_hd__fill_1
XFILLER_102_229 VGND VGND VPWR VPWR sky130_fd_sc_hd__decap_3
X_5163_ _5163_/A _5200_/B VGND VGND VPWR VPWR _7246_/D sky130_fd_sc_hd__and2_2
XFILLER_69_644 VGND VGND VPWR VPWR sky130_fd_sc_hd__decap_3
XFILLER_68_121 VGND VGND VPWR VPWR sky130_fd_sc_hd__decap_3
XFILLER_96_441 VGND VGND VPWR VPWR sky130_fd_sc_hd__decap_3
X_4114_ _7172_/Q _4459_/C1 _4348_/B1 _7140_/Q _4113_/X VGND VGND VPWR VPWR _4114_/X
+ sky130_fd_sc_hd__a221o_2
XFILLER_69_688 VGND VGND VPWR VPWR sky130_fd_sc_hd__decap_3
XFILLER_110_251 VGND VGND VPWR VPWR sky130_fd_sc_hd__fill_1
X_5094_ _5666_/A _6986_/D _5093_/X VGND VGND VPWR VPWR _5094_/X sky130_fd_sc_hd__a21o_2
XFILLER_84_625 VGND VGND VPWR VPWR sky130_fd_sc_hd__decap_3
XFILLER_110_262 VGND VGND VPWR VPWR sky130_fd_sc_hd__fill_1
XFILLER_83_113 VGND VGND VPWR VPWR sky130_fd_sc_hd__decap_3
XFILLER_56_338 VGND VGND VPWR VPWR sky130_fd_sc_hd__decap_3
X_4045_ _7085_/Q _4102_/B _4432_/B1 _4044_/X VGND VGND VPWR VPWR _4054_/A sky130_fd_sc_hd__o211a_2
XFILLER_56_349 VGND VGND VPWR VPWR sky130_fd_sc_hd__decap_3
XFILLER_84_669 VGND VGND VPWR VPWR sky130_fd_sc_hd__decap_3
XFILLER_71_308 VGND VGND VPWR VPWR sky130_fd_sc_hd__decap_3
XFILLER_25_703 VGND VGND VPWR VPWR sky130_fd_sc_hd__decap_3
XTAP_TAPCELL_ROW_69_1161 VGND VPWR sky130_fd_sc_hd__tapvpwrvgnd_1
XFILLER_52_522 VGND VGND VPWR VPWR sky130_fd_sc_hd__decap_3
XTAP_TAPCELL_ROW_35_720 VGND VPWR sky130_fd_sc_hd__tapvpwrvgnd_1
XFILLER_52_533 VGND VGND VPWR VPWR sky130_fd_sc_hd__decap_3
XFILLER_24_268 VGND VGND VPWR VPWR sky130_fd_sc_hd__decap_3
XFILLER_40_728 VGND VGND VPWR VPWR sky130_fd_sc_hd__decap_3
XFILLER_20_441 VGND VGND VPWR VPWR sky130_fd_sc_hd__fill_2
X_4878_ _4997_/A1 _6999_/D _4870_/Y _4877_/X VGND VGND VPWR VPWR _4878_/X sky130_fd_sc_hd__a211o_2
X_6617_ _6651_/A VGND VGND VPWR VPWR _6617_/Y sky130_fd_sc_hd__inv_2
X_3829_ _6908_/Q _3884_/A2 _3912_/B1 _6900_/Q VGND VGND VPWR VPWR _3829_/X sky130_fd_sc_hd__a22o_2
XFILLER_4_607 VGND VGND VPWR VPWR sky130_fd_sc_hd__decap_3
X_6548_ _6642_/A VGND VGND VPWR VPWR _6548_/Y sky130_fd_sc_hd__inv_2
XFILLER_109_6 VGND VGND VPWR VPWR sky130_fd_sc_hd__decap_3
X_6479_ _6642_/A VGND VGND VPWR VPWR _6479_/Y sky130_fd_sc_hd__inv_2
XFILLER_106_557 VGND VGND VPWR VPWR sky130_fd_sc_hd__decap_3
XFILLER_79_408 VGND VGND VPWR VPWR sky130_fd_sc_hd__decap_3
XFILLER_121_505 VGND VGND VPWR VPWR sky130_fd_sc_hd__decap_3
XFILLER_121_538 VGND VGND VPWR VPWR sky130_fd_sc_hd__decap_3
XFILLER_59_132 VGND VGND VPWR VPWR sky130_fd_sc_hd__fill_2
XFILLER_58_68 VGND VGND VPWR VPWR sky130_fd_sc_hd__decap_3
XFILLER_75_603 VGND VGND VPWR VPWR sky130_fd_sc_hd__decap_3
XFILLER_74_102 VGND VGND VPWR VPWR sky130_fd_sc_hd__decap_3
XFILLER_47_316 VGND VGND VPWR VPWR sky130_fd_sc_hd__decap_3
XFILLER_59_187 VGND VGND VPWR VPWR sky130_fd_sc_hd__decap_3
XFILLER_114_41 VGND VGND VPWR VPWR sky130_fd_sc_hd__decap_3
XFILLER_101_273 VGND VGND VPWR VPWR sky130_fd_sc_hd__decap_3
XFILLER_75_647 VGND VGND VPWR VPWR sky130_fd_sc_hd__decap_3
XFILLER_74_124 VGND VGND VPWR VPWR sky130_fd_sc_hd__decap_3
XFILLER_74_12 VGND VGND VPWR VPWR sky130_fd_sc_hd__decap_3
XFILLER_47_349 VGND VGND VPWR VPWR sky130_fd_sc_hd__fill_1
XFILLER_28_530 VGND VGND VPWR VPWR sky130_fd_sc_hd__fill_2
XFILLER_101_295 VGND VGND VPWR VPWR sky130_fd_sc_hd__fill_1
XFILLER_114_74 VGND VGND VPWR VPWR sky130_fd_sc_hd__decap_3
XFILLER_114_85 VGND VGND VPWR VPWR sky130_fd_sc_hd__decap_3
XFILLER_74_168 VGND VGND VPWR VPWR sky130_fd_sc_hd__decap_3
XFILLER_90_628 VGND VGND VPWR VPWR sky130_fd_sc_hd__decap_3
XFILLER_28_574 VGND VGND VPWR VPWR sky130_fd_sc_hd__decap_3
XFILLER_16_725 VGND VGND VPWR VPWR sky130_fd_sc_hd__decap_3
XFILLER_83_691 VGND VGND VPWR VPWR sky130_fd_sc_hd__decap_3
XFILLER_55_393 VGND VGND VPWR VPWR sky130_fd_sc_hd__decap_3
XFILLER_70_330 VGND VGND VPWR VPWR sky130_fd_sc_hd__decap_3
XFILLER_43_544 VGND VGND VPWR VPWR sky130_fd_sc_hd__fill_2
XFILLER_31_706 VGND VGND VPWR VPWR sky130_fd_sc_hd__decap_3
XFILLER_70_363 VGND VGND VPWR VPWR sky130_fd_sc_hd__fill_1
XFILLER_15_268 VGND VGND VPWR VPWR sky130_fd_sc_hd__decap_3
XFILLER_43_599 VGND VGND VPWR VPWR sky130_fd_sc_hd__decap_3
XFILLER_30_216 VGND VGND VPWR VPWR sky130_fd_sc_hd__decap_3
XTAP_TAPCELL_ROW_13_436 VGND VPWR sky130_fd_sc_hd__tapvpwrvgnd_1
XFILLER_11_441 VGND VGND VPWR VPWR sky130_fd_sc_hd__decap_3
XFILLER_90_99 VGND VGND VPWR VPWR sky130_fd_sc_hd__decap_3
XFILLER_11_463 VGND VGND VPWR VPWR sky130_fd_sc_hd__decap_3
XTAP_TAPCELL_ROW_96_1519 VGND VPWR sky130_fd_sc_hd__tapvpwrvgnd_1
XFILLER_7_445 VGND VGND VPWR VPWR sky130_fd_sc_hd__decap_3
XFILLER_109_340 VGND VGND VPWR VPWR sky130_fd_sc_hd__decap_3
XFILLER_98_728 VGND VGND VPWR VPWR sky130_fd_sc_hd__decap_3
XFILLER_3_662 VGND VGND VPWR VPWR sky130_fd_sc_hd__decap_3
XFILLER_97_216 VGND VGND VPWR VPWR sky130_fd_sc_hd__decap_3
XFILLER_3_673 VGND VGND VPWR VPWR sky130_fd_sc_hd__decap_3
XFILLER_112_516 VGND VGND VPWR VPWR sky130_fd_sc_hd__decap_3
XFILLER_2_183 VGND VGND VPWR VPWR sky130_fd_sc_hd__decap_3
XFILLER_78_463 VGND VGND VPWR VPWR sky130_fd_sc_hd__decap_3
XFILLER_66_603 VGND VGND VPWR VPWR sky130_fd_sc_hd__decap_3
XFILLER_120_560 VGND VGND VPWR VPWR sky130_fd_sc_hd__decap_3
XFILLER_66_636 VGND VGND VPWR VPWR sky130_fd_sc_hd__decap_3
XFILLER_65_113 VGND VGND VPWR VPWR sky130_fd_sc_hd__fill_2
XFILLER_93_455 VGND VGND VPWR VPWR sky130_fd_sc_hd__fill_2
XFILLER_66_669 VGND VGND VPWR VPWR sky130_fd_sc_hd__decap_3
XFILLER_81_606 VGND VGND VPWR VPWR sky130_fd_sc_hd__decap_3
XFILLER_81_617 VGND VGND VPWR VPWR sky130_fd_sc_hd__decap_3
XFILLER_53_308 VGND VGND VPWR VPWR sky130_fd_sc_hd__decap_3
XFILLER_80_116 VGND VGND VPWR VPWR sky130_fd_sc_hd__decap_3
XFILLER_34_511 VGND VGND VPWR VPWR sky130_fd_sc_hd__decap_3
XFILLER_19_585 VGND VGND VPWR VPWR sky130_fd_sc_hd__decap_3
XTAP_TAPCELL_ROW_105_1626 VGND VPWR sky130_fd_sc_hd__tapvpwrvgnd_1
XTAP_TAPCELL_ROW_105_1637 VGND VPWR sky130_fd_sc_hd__tapvpwrvgnd_1
XFILLER_80_138 VGND VGND VPWR VPWR sky130_fd_sc_hd__fill_2
XFILLER_61_330 VGND VGND VPWR VPWR sky130_fd_sc_hd__fill_1
XFILLER_34_555 VGND VGND VPWR VPWR sky130_fd_sc_hd__decap_3
XFILLER_61_363 VGND VGND VPWR VPWR sky130_fd_sc_hd__decap_3
X_4801_ _4801_/A _4801_/B VGND VGND VPWR VPWR _7003_/D sky130_fd_sc_hd__nor2_2
XFILLER_22_728 VGND VGND VPWR VPWR sky130_fd_sc_hd__decap_3
XFILLER_21_205 VGND VGND VPWR VPWR sky130_fd_sc_hd__decap_3
XFILLER_21_249 VGND VGND VPWR VPWR sky130_fd_sc_hd__decap_3
X_4663_ _4764_/B _4040_/B _4608_/Y _4659_/X _4662_/Y VGND VGND VPWR VPWR _5665_/A
+ sky130_fd_sc_hd__o32a_2
XFILLER_119_137 VGND VGND VPWR VPWR sky130_fd_sc_hd__decap_3
X_3614_ _3614_/A _3614_/B VGND VGND VPWR VPWR _3746_/B sky130_fd_sc_hd__and2_2
X_6402_ _6594_/A VGND VGND VPWR VPWR _6402_/Y sky130_fd_sc_hd__inv_2
X_7382_ _7387_/CLK _7382_/D _6662_/Y VGND VGND VPWR VPWR _7382_/Q sky130_fd_sc_hd__dfrtp_2
Xhold902 _7104_/Q VGND VGND VPWR VPWR _7104_/D sky130_fd_sc_hd__dlygate4sd3_1
Xhold913 _6707_/Q VGND VGND VPWR VPWR hold913/X sky130_fd_sc_hd__dlygate4sd3_1
X_3545_ _3545_/A _3545_/B VGND VGND VPWR VPWR _3636_/A sky130_fd_sc_hd__nor2_2
X_6333_ _6651_/A VGND VGND VPWR VPWR _6333_/Y sky130_fd_sc_hd__inv_2
Xhold924 _6690_/Q VGND VGND VPWR VPWR hold924/X sky130_fd_sc_hd__dlygate4sd3_1
Xhold935 _7043_/Q VGND VGND VPWR VPWR hold935/X sky130_fd_sc_hd__dlygate4sd3_1
XTAP_TAPCELL_ROW_116_1777 VGND VPWR sky130_fd_sc_hd__tapvpwrvgnd_1
Xhold946 _7404_/Q VGND VGND VPWR VPWR hold946/X sky130_fd_sc_hd__dlygate4sd3_1
XFILLER_89_706 VGND VGND VPWR VPWR sky130_fd_sc_hd__decap_3
XFILLER_115_343 VGND VGND VPWR VPWR sky130_fd_sc_hd__decap_3
Xhold957 _7394_/Q VGND VGND VPWR VPWR hold957/X sky130_fd_sc_hd__dlygate4sd3_1
Xhold968 _7279_/Q VGND VGND VPWR VPWR hold968/X sky130_fd_sc_hd__dlygate4sd3_1
X_6264_ _6658_/A VGND VGND VPWR VPWR _6264_/Y sky130_fd_sc_hd__inv_2
XFILLER_115_365 VGND VGND VPWR VPWR sky130_fd_sc_hd__fill_1
X_3476_ _7056_/Q _3558_/B _3429_/X VGND VGND VPWR VPWR _3502_/B sky130_fd_sc_hd__o21ai_2
Xhold979 _7019_/Q VGND VGND VPWR VPWR _5617_/A sky130_fd_sc_hd__dlygate4sd3_1
X_5215_ _5215_/A _5223_/B VGND VGND VPWR VPWR _7221_/D sky130_fd_sc_hd__and2_2
XFILLER_88_238 VGND VGND VPWR VPWR sky130_fd_sc_hd__decap_3
XFILLER_69_452 VGND VGND VPWR VPWR sky130_fd_sc_hd__decap_3
X_5146_ _5145_/A _3541_/X _5146_/B1 VGND VGND VPWR VPWR _5146_/Y sky130_fd_sc_hd__o21ai_2
XFILLER_57_614 VGND VGND VPWR VPWR sky130_fd_sc_hd__fill_2
XFILLER_84_400 VGND VGND VPWR VPWR sky130_fd_sc_hd__decap_3
XFILLER_56_102 VGND VGND VPWR VPWR sky130_fd_sc_hd__decap_3
XFILLER_29_316 VGND VGND VPWR VPWR sky130_fd_sc_hd__decap_3
XFILLER_111_582 VGND VGND VPWR VPWR sky130_fd_sc_hd__decap_3
XFILLER_84_433 VGND VGND VPWR VPWR sky130_fd_sc_hd__decap_3
XFILLER_57_647 VGND VGND VPWR VPWR sky130_fd_sc_hd__decap_3
XFILLER_56_124 VGND VGND VPWR VPWR sky130_fd_sc_hd__decap_3
XFILLER_96_293 VGND VGND VPWR VPWR sky130_fd_sc_hd__decap_3
X_5077_ _3904_/A _3863_/X _5658_/A VGND VGND VPWR VPWR _5077_/X sky130_fd_sc_hd__a21o_2
XFILLER_84_477 VGND VGND VPWR VPWR sky130_fd_sc_hd__fill_2
XFILLER_72_628 VGND VGND VPWR VPWR sky130_fd_sc_hd__decap_3
XFILLER_65_691 VGND VGND VPWR VPWR sky130_fd_sc_hd__decap_3
XFILLER_37_382 VGND VGND VPWR VPWR sky130_fd_sc_hd__fill_1
XFILLER_25_522 VGND VGND VPWR VPWR sky130_fd_sc_hd__decap_3
XFILLER_37_393 VGND VGND VPWR VPWR sky130_fd_sc_hd__fill_1
XFILLER_13_706 VGND VGND VPWR VPWR sky130_fd_sc_hd__decap_3
XTAP_TAPCELL_ROW_80_1309 VGND VPWR sky130_fd_sc_hd__tapvpwrvgnd_1
XFILLER_52_352 VGND VGND VPWR VPWR sky130_fd_sc_hd__decap_3
XFILLER_80_672 VGND VGND VPWR VPWR sky130_fd_sc_hd__decap_3
XFILLER_52_363 VGND VGND VPWR VPWR sky130_fd_sc_hd__fill_1
XFILLER_25_588 VGND VGND VPWR VPWR sky130_fd_sc_hd__decap_3
XFILLER_40_525 VGND VGND VPWR VPWR sky130_fd_sc_hd__decap_3
XFILLER_100_43 VGND VGND VPWR VPWR sky130_fd_sc_hd__fill_1
XFILLER_100_76 VGND VGND VPWR VPWR sky130_fd_sc_hd__decap_3
XFILLER_20_271 VGND VGND VPWR VPWR sky130_fd_sc_hd__decap_3
XFILLER_119_671 VGND VGND VPWR VPWR sky130_fd_sc_hd__fill_1
XFILLER_109_30 VGND VGND VPWR VPWR sky130_fd_sc_hd__decap_3
XFILLER_119_682 VGND VGND VPWR VPWR sky130_fd_sc_hd__decap_3
XFILLER_4_437 VGND VGND VPWR VPWR sky130_fd_sc_hd__decap_3
XFILLER_106_321 VGND VGND VPWR VPWR sky130_fd_sc_hd__decap_3
XFILLER_69_12 VGND VGND VPWR VPWR sky130_fd_sc_hd__decap_3
XFILLER_107_3 VGND VGND VPWR VPWR sky130_fd_sc_hd__decap_3
XFILLER_69_45 VGND VGND VPWR VPWR sky130_fd_sc_hd__decap_3
XFILLER_106_365 VGND VGND VPWR VPWR sky130_fd_sc_hd__decap_3
XTAP_TAPCELL_ROW_91_1449 VGND VPWR sky130_fd_sc_hd__tapvpwrvgnd_1
XFILLER_79_216 VGND VGND VPWR VPWR sky130_fd_sc_hd__decap_3
XFILLER_121_302 VGND VGND VPWR VPWR sky130_fd_sc_hd__decap_3
XFILLER_79_238 VGND VGND VPWR VPWR sky130_fd_sc_hd__decap_3
XFILLER_95_709 VGND VGND VPWR VPWR sky130_fd_sc_hd__decap_3
XFILLER_0_632 VGND VGND VPWR VPWR sky130_fd_sc_hd__decap_3
XFILLER_48_603 VGND VGND VPWR VPWR sky130_fd_sc_hd__decap_3
XFILLER_0_665 VGND VGND VPWR VPWR sky130_fd_sc_hd__decap_3
XFILLER_102_560 VGND VGND VPWR VPWR sky130_fd_sc_hd__decap_3
XFILLER_75_411 VGND VGND VPWR VPWR sky130_fd_sc_hd__decap_3
XFILLER_47_102 VGND VGND VPWR VPWR sky130_fd_sc_hd__fill_2
XFILLER_0_687 VGND VGND VPWR VPWR sky130_fd_sc_hd__decap_3
XFILLER_48_636 VGND VGND VPWR VPWR sky130_fd_sc_hd__decap_3
XFILLER_47_113 VGND VGND VPWR VPWR sky130_fd_sc_hd__decap_3
XFILLER_85_66 VGND VGND VPWR VPWR sky130_fd_sc_hd__decap_3
XFILLER_48_669 VGND VGND VPWR VPWR sky130_fd_sc_hd__decap_3
XFILLER_85_88 VGND VGND VPWR VPWR sky130_fd_sc_hd__decap_3
XFILLER_47_157 VGND VGND VPWR VPWR sky130_fd_sc_hd__decap_3
XFILLER_63_617 VGND VGND VPWR VPWR sky130_fd_sc_hd__decap_3
XFILLER_35_308 VGND VGND VPWR VPWR sky130_fd_sc_hd__decap_3
XTAP_TAPCELL_ROW_18_506 VGND VPWR sky130_fd_sc_hd__tapvpwrvgnd_1
XFILLER_75_488 VGND VGND VPWR VPWR sky130_fd_sc_hd__fill_2
XFILLER_28_360 VGND VGND VPWR VPWR sky130_fd_sc_hd__decap_3
XFILLER_18_71 VGND VGND VPWR VPWR sky130_fd_sc_hd__decap_3
XFILLER_75_499 VGND VGND VPWR VPWR sky130_fd_sc_hd__fill_1
XFILLER_28_371 VGND VGND VPWR VPWR sky130_fd_sc_hd__decap_3
XFILLER_18_93 VGND VGND VPWR VPWR sky130_fd_sc_hd__decap_3
XFILLER_16_522 VGND VGND VPWR VPWR sky130_fd_sc_hd__decap_3
XTAP_TAPCELL_ROW_46_859 VGND VPWR sky130_fd_sc_hd__tapvpwrvgnd_1
XFILLER_62_138 VGND VGND VPWR VPWR sky130_fd_sc_hd__fill_2
XFILLER_16_555 VGND VGND VPWR VPWR sky130_fd_sc_hd__decap_3
XFILLER_71_650 VGND VGND VPWR VPWR sky130_fd_sc_hd__decap_3
XFILLER_43_374 VGND VGND VPWR VPWR sky130_fd_sc_hd__decap_3
XFILLER_71_694 VGND VGND VPWR VPWR sky130_fd_sc_hd__decap_3
XFILLER_70_171 VGND VGND VPWR VPWR sky130_fd_sc_hd__decap_3
XFILLER_70_182 VGND VGND VPWR VPWR sky130_fd_sc_hd__decap_3
XFILLER_34_70 VGND VGND VPWR VPWR sky130_fd_sc_hd__decap_3
XFILLER_34_81 VGND VGND VPWR VPWR sky130_fd_sc_hd__decap_3
XFILLER_8_710 VGND VGND VPWR VPWR sky130_fd_sc_hd__decap_3
XTAP_TAPCELL_ROW_100_1567 VGND VPWR sky130_fd_sc_hd__tapvpwrvgnd_1
XFILLER_7_220 VGND VGND VPWR VPWR sky130_fd_sc_hd__decap_3
XFILLER_7_275 VGND VGND VPWR VPWR sky130_fd_sc_hd__decap_3
XFILLER_116_118 VGND VGND VPWR VPWR sky130_fd_sc_hd__fill_2
X_3330_ _3340_/A VGND VGND VPWR VPWR _3330_/Y sky130_fd_sc_hd__inv_2
XFILLER_98_547 VGND VGND VPWR VPWR sky130_fd_sc_hd__decap_3
XFILLER_3_470 VGND VGND VPWR VPWR sky130_fd_sc_hd__decap_3
XFILLER_3_492 VGND VGND VPWR VPWR sky130_fd_sc_hd__decap_3
X_5000_ _6991_/Q _5026_/A VGND VGND VPWR VPWR _5001_/B sky130_fd_sc_hd__nor2_2
XFILLER_112_368 VGND VGND VPWR VPWR sky130_fd_sc_hd__fill_1
XFILLER_85_219 VGND VGND VPWR VPWR sky130_fd_sc_hd__decap_3
XFILLER_39_614 VGND VGND VPWR VPWR sky130_fd_sc_hd__fill_2
XFILLER_22_3 VGND VGND VPWR VPWR sky130_fd_sc_hd__decap_3
Xsingle_cycle_cpu VGND VGND VPWR VPWR single_cycle_cpu/HI instruction_out[19] sky130_fd_sc_hd__conb_1
XFILLER_38_102 VGND VGND VPWR VPWR sky130_fd_sc_hd__decap_3
XFILLER_94_731 VGND VGND VPWR VPWR sky130_fd_sc_hd__decap_3
XFILLER_78_293 VGND VGND VPWR VPWR sky130_fd_sc_hd__decap_3
XFILLER_39_647 VGND VGND VPWR VPWR sky130_fd_sc_hd__decap_3
XFILLER_38_135 VGND VGND VPWR VPWR sky130_fd_sc_hd__decap_3
XFILLER_66_466 VGND VGND VPWR VPWR sky130_fd_sc_hd__fill_1
XFILLER_38_157 VGND VGND VPWR VPWR sky130_fd_sc_hd__decap_3
XFILLER_93_263 VGND VGND VPWR VPWR sky130_fd_sc_hd__decap_3
XFILLER_81_403 VGND VGND VPWR VPWR sky130_fd_sc_hd__fill_2
XFILLER_66_477 VGND VGND VPWR VPWR sky130_fd_sc_hd__decap_3
XFILLER_54_628 VGND VGND VPWR VPWR sky130_fd_sc_hd__decap_3
X_6951_ clkload4/A _6951_/D VGND VGND VPWR VPWR _6951_/Q sky130_fd_sc_hd__dfxtp_2
XFILLER_19_371 VGND VGND VPWR VPWR sky130_fd_sc_hd__decap_3
XFILLER_47_691 VGND VGND VPWR VPWR sky130_fd_sc_hd__decap_3
XTAP_TAPCELL_ROW_66_1120 VGND VPWR sky130_fd_sc_hd__tapvpwrvgnd_1
XFILLER_19_393 VGND VGND VPWR VPWR sky130_fd_sc_hd__decap_3
XTAP_TAPCELL_ROW_66_1131 VGND VPWR sky130_fd_sc_hd__tapvpwrvgnd_1
XFILLER_81_458 VGND VGND VPWR VPWR sky130_fd_sc_hd__decap_3
X_6882_ _7215_/CLK _6882_/D VGND VGND VPWR VPWR _6882_/Q sky130_fd_sc_hd__dfxtp_2
XFILLER_34_352 VGND VGND VPWR VPWR sky130_fd_sc_hd__decap_3
XFILLER_62_672 VGND VGND VPWR VPWR sky130_fd_sc_hd__decap_3
XFILLER_61_160 VGND VGND VPWR VPWR sky130_fd_sc_hd__decap_3
XFILLER_22_536 VGND VGND VPWR VPWR sky130_fd_sc_hd__decap_3
XTAP_TAPCELL_ROW_118_1806 VGND VPWR sky130_fd_sc_hd__tapvpwrvgnd_1
X_5695_ _7353_/Q hold911/X _5737_/S VGND VGND VPWR VPWR _6697_/D sky130_fd_sc_hd__mux2_2
XFILLER_108_619 VGND VGND VPWR VPWR sky130_fd_sc_hd__decap_3
X_4646_ _4646_/A _4646_/B VGND VGND VPWR VPWR _4646_/Y sky130_fd_sc_hd__nand2_2
Xhold710 _6957_/Q VGND VGND VPWR VPWR _6957_/D sky130_fd_sc_hd__dlygate4sd3_1
X_4577_ _4577_/A _4577_/B VGND VGND VPWR VPWR _7292_/D sky130_fd_sc_hd__and2_2
Xhold721 _6903_/Q VGND VGND VPWR VPWR _6903_/D sky130_fd_sc_hd__dlygate4sd3_1
X_7365_ _7365_/CLK _7365_/D _6645_/Y VGND VGND VPWR VPWR _7365_/Q sky130_fd_sc_hd__dfrtp_2
Xhold732 _6831_/Q VGND VGND VPWR VPWR _6831_/D sky130_fd_sc_hd__dlygate4sd3_1
XTAP_TAPCELL_ROW_77_1271 VGND VPWR sky130_fd_sc_hd__tapvpwrvgnd_1
Xhold743 _6885_/Q VGND VGND VPWR VPWR _6885_/D sky130_fd_sc_hd__dlygate4sd3_1
XFILLER_116_663 VGND VGND VPWR VPWR sky130_fd_sc_hd__decap_3
XFILLER_115_140 VGND VGND VPWR VPWR sky130_fd_sc_hd__decap_3
X_6316_ _6624_/A VGND VGND VPWR VPWR _6316_/Y sky130_fd_sc_hd__inv_2
Xhold754 _6830_/Q VGND VGND VPWR VPWR _6830_/D sky130_fd_sc_hd__dlygate4sd3_1
X_3528_ _3528_/A _5118_/D VGND VGND VPWR VPWR _5659_/A sky130_fd_sc_hd__or2_2
Xhold765 _6764_/Q VGND VGND VPWR VPWR _6764_/D sky130_fd_sc_hd__dlygate4sd3_1
XFILLER_103_302 VGND VGND VPWR VPWR sky130_fd_sc_hd__decap_3
Xhold776 _6879_/Q VGND VGND VPWR VPWR _6879_/D sky130_fd_sc_hd__dlygate4sd3_1
X_7296_ _7359_/CLK _7296_/D _6576_/Y VGND VGND VPWR VPWR _7296_/Q sky130_fd_sc_hd__dfrtp_2
XFILLER_116_696 VGND VGND VPWR VPWR sky130_fd_sc_hd__decap_3
Xhold787 _6938_/Q VGND VGND VPWR VPWR _6938_/D sky130_fd_sc_hd__dlygate4sd3_1
XFILLER_89_547 VGND VGND VPWR VPWR sky130_fd_sc_hd__decap_3
XFILLER_103_324 VGND VGND VPWR VPWR sky130_fd_sc_hd__decap_3
Xhold798 _6892_/Q VGND VGND VPWR VPWR _6892_/D sky130_fd_sc_hd__dlygate4sd3_1
X_3459_ _7217_/Q _4349_/B1 _4341_/B1 _7121_/Q VGND VGND VPWR VPWR _3459_/X sky130_fd_sc_hd__a22o_2
XFILLER_77_709 VGND VGND VPWR VPWR sky130_fd_sc_hd__decap_3
XFILLER_103_346 VGND VGND VPWR VPWR sky130_fd_sc_hd__decap_3
XFILLER_103_368 VGND VGND VPWR VPWR sky130_fd_sc_hd__decap_3
XFILLER_57_411 VGND VGND VPWR VPWR sky130_fd_sc_hd__decap_3
XFILLER_97_591 VGND VGND VPWR VPWR sky130_fd_sc_hd__decap_3
XFILLER_69_293 VGND VGND VPWR VPWR sky130_fd_sc_hd__decap_3
X_5129_ _5129_/A _5129_/B VGND VGND VPWR VPWR _5130_/C sky130_fd_sc_hd__nor2_2
XFILLER_84_241 VGND VGND VPWR VPWR sky130_fd_sc_hd__decap_3
XFILLER_29_157 VGND VGND VPWR VPWR sky130_fd_sc_hd__decap_3
XFILLER_45_617 VGND VGND VPWR VPWR sky130_fd_sc_hd__decap_3
XFILLER_84_263 VGND VGND VPWR VPWR sky130_fd_sc_hd__decap_3
XFILLER_84_296 VGND VGND VPWR VPWR sky130_fd_sc_hd__fill_2
XFILLER_53_650 VGND VGND VPWR VPWR sky130_fd_sc_hd__decap_3
XFILLER_111_42 VGND VGND VPWR VPWR sky130_fd_sc_hd__decap_3
XTAP_TAPCELL_ROW_43_829 VGND VPWR sky130_fd_sc_hd__tapvpwrvgnd_1
XFILLER_25_374 VGND VGND VPWR VPWR sky130_fd_sc_hd__decap_3
XFILLER_53_694 VGND VGND VPWR VPWR sky130_fd_sc_hd__decap_3
XFILLER_71_24 VGND VGND VPWR VPWR sky130_fd_sc_hd__decap_3
XFILLER_71_57 VGND VGND VPWR VPWR sky130_fd_sc_hd__decap_3
XTAP_TAPCELL_ROW_23_564 VGND VPWR sky130_fd_sc_hd__tapvpwrvgnd_1
XFILLER_21_580 VGND VGND VPWR VPWR sky130_fd_sc_hd__decap_3
XFILLER_5_724 VGND VGND VPWR VPWR sky130_fd_sc_hd__decap_3
XFILLER_4_212 VGND VGND VPWR VPWR sky130_fd_sc_hd__decap_3
XFILLER_119_490 VGND VGND VPWR VPWR sky130_fd_sc_hd__decap_3
XFILLER_107_641 VGND VGND VPWR VPWR sky130_fd_sc_hd__decap_3
XFILLER_4_245 VGND VGND VPWR VPWR sky130_fd_sc_hd__decap_3
XFILLER_4_256 VGND VGND VPWR VPWR sky130_fd_sc_hd__decap_3
XFILLER_4_278 VGND VGND VPWR VPWR sky130_fd_sc_hd__decap_3
XFILLER_107_685 VGND VGND VPWR VPWR sky130_fd_sc_hd__decap_3
XFILLER_122_622 VGND VGND VPWR VPWR sky130_fd_sc_hd__decap_3
XFILLER_106_195 VGND VGND VPWR VPWR sky130_fd_sc_hd__fill_1
XFILLER_96_32 VGND VGND VPWR VPWR sky130_fd_sc_hd__decap_3
XFILLER_122_666 VGND VGND VPWR VPWR sky130_fd_sc_hd__decap_3
XFILLER_95_517 VGND VGND VPWR VPWR sky130_fd_sc_hd__fill_1
XFILLER_122_699 VGND VGND VPWR VPWR sky130_fd_sc_hd__fill_1
XFILLER_88_580 VGND VGND VPWR VPWR sky130_fd_sc_hd__decap_3
XFILLER_76_731 VGND VGND VPWR VPWR sky130_fd_sc_hd__decap_3
XFILLER_96_98 VGND VGND VPWR VPWR sky130_fd_sc_hd__decap_3
XFILLER_48_455 VGND VGND VPWR VPWR sky130_fd_sc_hd__fill_1
XFILLER_48_466 VGND VGND VPWR VPWR sky130_fd_sc_hd__decap_3
XFILLER_48_477 VGND VGND VPWR VPWR sky130_fd_sc_hd__decap_3
XFILLER_91_712 VGND VGND VPWR VPWR sky130_fd_sc_hd__decap_3
XFILLER_63_403 VGND VGND VPWR VPWR sky130_fd_sc_hd__fill_2
XFILLER_36_628 VGND VGND VPWR VPWR sky130_fd_sc_hd__decap_3
XFILLER_90_211 VGND VGND VPWR VPWR sky130_fd_sc_hd__decap_3
XFILLER_63_425 VGND VGND VPWR VPWR sky130_fd_sc_hd__decap_3
XFILLER_35_116 VGND VGND VPWR VPWR sky130_fd_sc_hd__decap_3
Xplace403 _4497_/S VGND VGND VPWR VPWR _4486_/S sky130_fd_sc_hd__buf_2
XFILLER_29_691 VGND VGND VPWR VPWR sky130_fd_sc_hd__decap_3
Xplace414 _4399_/A2 VGND VGND VPWR VPWR _4437_/B1 sky130_fd_sc_hd__buf_2
Xplace425 _3958_/S VGND VGND VPWR VPWR _3935_/S sky130_fd_sc_hd__buf_2
XFILLER_63_458 VGND VGND VPWR VPWR sky130_fd_sc_hd__decap_3
XFILLER_16_330 VGND VGND VPWR VPWR sky130_fd_sc_hd__decap_3
Xplace436 _3344_/Y VGND VGND VPWR VPWR _4677_/B sky130_fd_sc_hd__buf_2
Xplace447 _4307_/A2 VGND VGND VPWR VPWR _4353_/A2 sky130_fd_sc_hd__buf_2
XFILLER_16_352 VGND VGND VPWR VPWR sky130_fd_sc_hd__decap_3
Xplace458 _6980_/Q VGND VGND VPWR VPWR _3327_/B sky130_fd_sc_hd__buf_2
XFILLER_44_672 VGND VGND VPWR VPWR sky130_fd_sc_hd__decap_3
XFILLER_16_385 VGND VGND VPWR VPWR sky130_fd_sc_hd__decap_3
XFILLER_31_311 VGND VGND VPWR VPWR sky130_fd_sc_hd__decap_3
XFILLER_31_355 VGND VGND VPWR VPWR sky130_fd_sc_hd__decap_3
XFILLER_31_377 VGND VGND VPWR VPWR sky130_fd_sc_hd__decap_3
XTAP_TAPCELL_ROW_61_1061 VGND VPWR sky130_fd_sc_hd__tapvpwrvgnd_1
XFILLER_31_399 VGND VGND VPWR VPWR sky130_fd_sc_hd__fill_1
XFILLER_12_580 VGND VGND VPWR VPWR sky130_fd_sc_hd__decap_3
XFILLER_8_551 VGND VGND VPWR VPWR sky130_fd_sc_hd__decap_3
XFILLER_8_584 VGND VGND VPWR VPWR sky130_fd_sc_hd__decap_3
XFILLER_8_595 VGND VGND VPWR VPWR sky130_fd_sc_hd__decap_3
XFILLER_117_438 VGND VGND VPWR VPWR sky130_fd_sc_hd__fill_2
XANTENNA_1 _5658_/D VGND VGND VPWR VPWR sky130_fd_sc_hd__diode_2
X_4431_ _7271_/Q _4431_/A2 _4428_/X _4430_/X VGND VGND VPWR VPWR _4431_/X sky130_fd_sc_hd__a211o_2
XFILLER_6_85 VGND VGND VPWR VPWR sky130_fd_sc_hd__decap_3
X_4362_ _4362_/A _4362_/B _4362_/C VGND VGND VPWR VPWR _4362_/X sky130_fd_sc_hd__and3_2
X_7150_ _7370_/CLK _7150_/D _6430_/Y VGND VGND VPWR VPWR _7150_/Q sky130_fd_sc_hd__dfrtp_2
XFILLER_113_600 VGND VGND VPWR VPWR sky130_fd_sc_hd__decap_3
XTAP_TAPCELL_ROW_113_1736 VGND VPWR sky130_fd_sc_hd__tapvpwrvgnd_1
X_3313_ _3561_/B _3327_/B _6981_/Q _6982_/Q VGND VGND VPWR VPWR _4467_/B sky130_fd_sc_hd__nand4b_4
XFILLER_113_644 VGND VGND VPWR VPWR sky130_fd_sc_hd__decap_3
X_7081_ _7405_/CLK _7081_/D _6361_/Y VGND VGND VPWR VPWR _7081_/Q sky130_fd_sc_hd__dfrtp_2
X_4293_ _4612_/A _4612_/B VGND VGND VPWR VPWR _4293_/X sky130_fd_sc_hd__and2b_2
XFILLER_59_709 VGND VGND VPWR VPWR sky130_fd_sc_hd__decap_3
XFILLER_113_688 VGND VGND VPWR VPWR sky130_fd_sc_hd__decap_3
XFILLER_86_528 VGND VGND VPWR VPWR sky130_fd_sc_hd__decap_3
XFILLER_112_165 VGND VGND VPWR VPWR sky130_fd_sc_hd__decap_3
XFILLER_112_187 VGND VGND VPWR VPWR sky130_fd_sc_hd__fill_1
XFILLER_79_591 VGND VGND VPWR VPWR sky130_fd_sc_hd__decap_3
XFILLER_82_701 VGND VGND VPWR VPWR sky130_fd_sc_hd__decap_3
XFILLER_27_617 VGND VGND VPWR VPWR sky130_fd_sc_hd__decap_3
XFILLER_94_583 VGND VGND VPWR VPWR sky130_fd_sc_hd__decap_3
XFILLER_26_105 VGND VGND VPWR VPWR sky130_fd_sc_hd__decap_3
XFILLER_82_734 VGND VGND VPWR VPWR sky130_fd_sc_hd__fill_1
XFILLER_54_436 VGND VGND VPWR VPWR sky130_fd_sc_hd__decap_3
XFILLER_26_127 VGND VGND VPWR VPWR sky130_fd_sc_hd__decap_3
X_6934_ _6942_/CLK _6934_/D VGND VGND VPWR VPWR _6934_/Q sky130_fd_sc_hd__dfxtp_2
XFILLER_81_255 VGND VGND VPWR VPWR sky130_fd_sc_hd__decap_3
XFILLER_35_650 VGND VGND VPWR VPWR sky130_fd_sc_hd__decap_3
XFILLER_22_300 VGND VGND VPWR VPWR sky130_fd_sc_hd__decap_3
X_6865_ _7378_/CLK _6865_/D VGND VGND VPWR VPWR _6865_/Q sky130_fd_sc_hd__dfxtp_2
XFILLER_35_694 VGND VGND VPWR VPWR sky130_fd_sc_hd__decap_3
XFILLER_50_631 VGND VGND VPWR VPWR sky130_fd_sc_hd__decap_3
XFILLER_22_322 VGND VGND VPWR VPWR sky130_fd_sc_hd__decap_3
XFILLER_22_344 VGND VGND VPWR VPWR sky130_fd_sc_hd__decap_3
X_6796_ _7401_/CLK _6796_/D VGND VGND VPWR VPWR _6796_/Q sky130_fd_sc_hd__dfxtp_2
XFILLER_50_675 VGND VGND VPWR VPWR sky130_fd_sc_hd__decap_3
XFILLER_10_517 VGND VGND VPWR VPWR sky130_fd_sc_hd__decap_3
XFILLER_10_539 VGND VGND VPWR VPWR sky130_fd_sc_hd__decap_3
XTAP_TAPCELL_ROW_20_523 VGND VPWR sky130_fd_sc_hd__tapvpwrvgnd_1
XTAP_TAPCELL_ROW_79_1300 VGND VPWR sky130_fd_sc_hd__tapvpwrvgnd_1
XFILLER_108_405 VGND VGND VPWR VPWR sky130_fd_sc_hd__decap_3
X_5678_ _7345_/Q hold912/X _5737_/S VGND VGND VPWR VPWR _6689_/D sky130_fd_sc_hd__mux2_2
XFILLER_108_427 VGND VGND VPWR VPWR sky130_fd_sc_hd__fill_2
X_4629_ _4629_/A _4629_/B VGND VGND VPWR VPWR _4629_/Y sky130_fd_sc_hd__nor2_2
XFILLER_123_419 VGND VGND VPWR VPWR sky130_fd_sc_hd__fill_1
XFILLER_2_716 VGND VGND VPWR VPWR sky130_fd_sc_hd__decap_3
XFILLER_116_460 VGND VGND VPWR VPWR sky130_fd_sc_hd__decap_3
X_7348_ _7352_/CLK _7348_/D _6628_/Y VGND VGND VPWR VPWR _7348_/Q sky130_fd_sc_hd__dfrtp_2
XFILLER_89_311 VGND VGND VPWR VPWR sky130_fd_sc_hd__decap_3
XFILLER_1_215 VGND VGND VPWR VPWR sky130_fd_sc_hd__decap_3
XFILLER_104_622 VGND VGND VPWR VPWR sky130_fd_sc_hd__decap_3
Xhold584 _6874_/Q VGND VGND VPWR VPWR _6874_/D sky130_fd_sc_hd__dlygate4sd3_1
Xhold595 _6932_/Q VGND VGND VPWR VPWR _6932_/D sky130_fd_sc_hd__dlygate4sd3_1
X_7279_ _7279_/CLK _7279_/D _6559_/Y VGND VGND VPWR VPWR _7279_/Q sky130_fd_sc_hd__dfrtp_2
XFILLER_104_666 VGND VGND VPWR VPWR sky130_fd_sc_hd__decap_3
XFILLER_104_699 VGND VGND VPWR VPWR sky130_fd_sc_hd__fill_1
XFILLER_103_187 VGND VGND VPWR VPWR sky130_fd_sc_hd__fill_1
XFILLER_66_24 VGND VGND VPWR VPWR sky130_fd_sc_hd__decap_3
XFILLER_58_731 VGND VGND VPWR VPWR sky130_fd_sc_hd__decap_3
XFILLER_66_35 VGND VGND VPWR VPWR sky130_fd_sc_hd__decap_3
XFILLER_85_561 VGND VGND VPWR VPWR sky130_fd_sc_hd__decap_3
XFILLER_57_252 VGND VGND VPWR VPWR sky130_fd_sc_hd__decap_3
XFILLER_73_712 VGND VGND VPWR VPWR sky130_fd_sc_hd__decap_3
XFILLER_18_628 VGND VGND VPWR VPWR sky130_fd_sc_hd__decap_3
XFILLER_85_594 VGND VGND VPWR VPWR sky130_fd_sc_hd__decap_3
XFILLER_17_116 VGND VGND VPWR VPWR sky130_fd_sc_hd__decap_3
XFILLER_122_41 VGND VGND VPWR VPWR sky130_fd_sc_hd__decap_3
XTAP_TAPCELL_ROW_28_634 VGND VPWR sky130_fd_sc_hd__tapvpwrvgnd_1
XFILLER_72_233 VGND VGND VPWR VPWR sky130_fd_sc_hd__decap_3
XFILLER_82_12 VGND VGND VPWR VPWR sky130_fd_sc_hd__decap_3
XFILLER_122_74 VGND VGND VPWR VPWR sky130_fd_sc_hd__decap_3
XFILLER_72_266 VGND VGND VPWR VPWR sky130_fd_sc_hd__decap_3
XFILLER_122_85 VGND VGND VPWR VPWR sky130_fd_sc_hd__decap_3
XTAP_TAPCELL_ROW_0_270 VGND VPWR sky130_fd_sc_hd__tapvpwrvgnd_1
XTAP_TAPCELL_ROW_56_998 VGND VPWR sky130_fd_sc_hd__tapvpwrvgnd_1
XFILLER_26_672 VGND VGND VPWR VPWR sky130_fd_sc_hd__decap_3
XFILLER_72_288 VGND VGND VPWR VPWR sky130_fd_sc_hd__decap_3
XFILLER_41_620 VGND VGND VPWR VPWR sky130_fd_sc_hd__decap_3
XFILLER_13_311 VGND VGND VPWR VPWR sky130_fd_sc_hd__fill_1
XFILLER_13_333 VGND VGND VPWR VPWR sky130_fd_sc_hd__decap_3
XFILLER_41_653 VGND VGND VPWR VPWR sky130_fd_sc_hd__decap_3
XFILLER_40_141 VGND VGND VPWR VPWR sky130_fd_sc_hd__decap_3
XFILLER_15_83 VGND VGND VPWR VPWR sky130_fd_sc_hd__fill_2
XFILLER_13_377 VGND VGND VPWR VPWR sky130_fd_sc_hd__decap_3
XFILLER_9_337 VGND VGND VPWR VPWR sky130_fd_sc_hd__decap_3
XFILLER_41_697 VGND VGND VPWR VPWR sky130_fd_sc_hd__decap_3
XFILLER_13_399 VGND VGND VPWR VPWR sky130_fd_sc_hd__decap_3
XFILLER_31_60 VGND VGND VPWR VPWR sky130_fd_sc_hd__decap_3
XFILLER_5_543 VGND VGND VPWR VPWR sky130_fd_sc_hd__decap_3
XFILLER_31_93 VGND VGND VPWR VPWR sky130_fd_sc_hd__fill_2
XFILLER_114_408 VGND VGND VPWR VPWR sky130_fd_sc_hd__fill_1
XFILLER_99_108 VGND VGND VPWR VPWR sky130_fd_sc_hd__fill_1
XFILLER_5_576 VGND VGND VPWR VPWR sky130_fd_sc_hd__decap_3
XFILLER_122_441 VGND VGND VPWR VPWR sky130_fd_sc_hd__decap_3
XTAP_TAPCELL_ROW_8_370 VGND VPWR sky130_fd_sc_hd__tapvpwrvgnd_1
XFILLER_122_474 VGND VGND VPWR VPWR sky130_fd_sc_hd__fill_2
XFILLER_110_625 VGND VGND VPWR VPWR sky130_fd_sc_hd__decap_3
XFILLER_95_325 VGND VGND VPWR VPWR sky130_fd_sc_hd__fill_1
XFILLER_0_281 VGND VGND VPWR VPWR sky130_fd_sc_hd__decap_3
XFILLER_110_669 VGND VGND VPWR VPWR sky130_fd_sc_hd__decap_3
XFILLER_64_701 VGND VGND VPWR VPWR sky130_fd_sc_hd__decap_3
XFILLER_64_734 VGND VGND VPWR VPWR sky130_fd_sc_hd__fill_1
XFILLER_36_458 VGND VGND VPWR VPWR sky130_fd_sc_hd__decap_3
XFILLER_91_564 VGND VGND VPWR VPWR sky130_fd_sc_hd__decap_3
XFILLER_17_650 VGND VGND VPWR VPWR sky130_fd_sc_hd__decap_3
XFILLER_51_417 VGND VGND VPWR VPWR sky130_fd_sc_hd__decap_3
XFILLER_91_597 VGND VGND VPWR VPWR sky130_fd_sc_hd__decap_3
X_3931_ _7374_/Q _4474_/A0 _3943_/S VGND VGND VPWR VPWR _7374_/D sky130_fd_sc_hd__mux2_2
XFILLER_63_299 VGND VGND VPWR VPWR sky130_fd_sc_hd__decap_3
XFILLER_51_439 VGND VGND VPWR VPWR sky130_fd_sc_hd__decap_3
XFILLER_17_694 VGND VGND VPWR VPWR sky130_fd_sc_hd__decap_3
XFILLER_44_480 VGND VGND VPWR VPWR sky130_fd_sc_hd__decap_3
Xplace277 _3871_/B1 VGND VGND VPWR VPWR _3925_/B1 sky130_fd_sc_hd__buf_2
XFILLER_32_631 VGND VGND VPWR VPWR sky130_fd_sc_hd__decap_3
Xplace288 _3851_/A2 VGND VGND VPWR VPWR _3886_/A2 sky130_fd_sc_hd__buf_2
Xplace299 _3898_/B1 VGND VGND VPWR VPWR _3759_/A2 sky130_fd_sc_hd__buf_2
X_6650_ _6650_/A VGND VGND VPWR VPWR _6650_/Y sky130_fd_sc_hd__inv_2
XFILLER_31_130 VGND VGND VPWR VPWR sky130_fd_sc_hd__decap_3
X_3862_ _6923_/Q _3906_/A2 _3898_/B1 _6787_/Q VGND VGND VPWR VPWR _3862_/X sky130_fd_sc_hd__a22o_2
XFILLER_32_675 VGND VGND VPWR VPWR sky130_fd_sc_hd__decap_3
XFILLER_31_163 VGND VGND VPWR VPWR sky130_fd_sc_hd__decap_3
X_6581_ _6581_/A VGND VGND VPWR VPWR _6581_/Y sky130_fd_sc_hd__inv_2
X_3793_ _6756_/Q _3878_/A2 _3878_/B1 _6768_/Q VGND VGND VPWR VPWR _3793_/X sky130_fd_sc_hd__a22o_2
XFILLER_118_725 VGND VGND VPWR VPWR sky130_fd_sc_hd__decap_3
XFILLER_117_202 VGND VGND VPWR VPWR sky130_fd_sc_hd__fill_1
XFILLER_117_246 VGND VGND VPWR VPWR sky130_fd_sc_hd__fill_2
XFILLER_117_268 VGND VGND VPWR VPWR sky130_fd_sc_hd__fill_2
X_7202_ _7395_/CLK _7202_/D _6482_/Y VGND VGND VPWR VPWR _7202_/Q sky130_fd_sc_hd__dfrtp_2
X_4414_ _7240_/Q _4414_/A2 _3943_/S _7208_/Q VGND VGND VPWR VPWR _4414_/X sky130_fd_sc_hd__a22o_2
XFILLER_99_620 VGND VGND VPWR VPWR sky130_fd_sc_hd__decap_3
XTAP_TAPCELL_ROW_74_1230 VGND VPWR sky130_fd_sc_hd__tapvpwrvgnd_1
X_5394_ _5394_/A0 _4964_/X _5398_/S VGND VGND VPWR VPWR _7136_/D sky130_fd_sc_hd__mux2_2
XFILLER_99_653 VGND VGND VPWR VPWR sky130_fd_sc_hd__decap_3
X_7133_ _7356_/CLK _7133_/D _6413_/Y VGND VGND VPWR VPWR _7133_/Q sky130_fd_sc_hd__dfrtp_2
XFILLER_98_130 VGND VGND VPWR VPWR sky130_fd_sc_hd__fill_2
XFILLER_113_430 VGND VGND VPWR VPWR sky130_fd_sc_hd__decap_3
X_4345_ _4343_/X _4345_/B VGND VGND VPWR VPWR _5101_/B sky130_fd_sc_hd__nand2b_2
XFILLER_98_141 VGND VGND VPWR VPWR sky130_fd_sc_hd__fill_1
XFILLER_101_603 VGND VGND VPWR VPWR sky130_fd_sc_hd__decap_3
XFILLER_98_163 VGND VGND VPWR VPWR sky130_fd_sc_hd__decap_3
XFILLER_99_697 VGND VGND VPWR VPWR sky130_fd_sc_hd__decap_3
X_7064_ _7387_/CLK _7064_/D _6344_/Y VGND VGND VPWR VPWR _7064_/Q sky130_fd_sc_hd__dfrtp_2
XFILLER_98_185 VGND VGND VPWR VPWR sky130_fd_sc_hd__decap_3
XFILLER_101_647 VGND VGND VPWR VPWR sky130_fd_sc_hd__decap_3
XFILLER_86_358 VGND VGND VPWR VPWR sky130_fd_sc_hd__decap_3
XFILLER_67_550 VGND VGND VPWR VPWR sky130_fd_sc_hd__decap_3
XFILLER_39_252 VGND VGND VPWR VPWR sky130_fd_sc_hd__decap_3
XFILLER_100_168 VGND VGND VPWR VPWR sky130_fd_sc_hd__decap_3
XFILLER_55_712 VGND VGND VPWR VPWR sky130_fd_sc_hd__decap_3
XFILLER_54_211 VGND VGND VPWR VPWR sky130_fd_sc_hd__decap_3
XFILLER_94_391 VGND VGND VPWR VPWR sky130_fd_sc_hd__fill_1
XFILLER_27_436 VGND VGND VPWR VPWR sky130_fd_sc_hd__decap_3
XFILLER_27_447 VGND VGND VPWR VPWR sky130_fd_sc_hd__fill_1
XFILLER_70_704 VGND VGND VPWR VPWR sky130_fd_sc_hd__decap_3
XFILLER_15_609 VGND VGND VPWR VPWR sky130_fd_sc_hd__decap_3
XFILLER_82_586 VGND VGND VPWR VPWR sky130_fd_sc_hd__fill_2
XTAP_TAPCELL_ROW_85_1370 VGND VPWR sky130_fd_sc_hd__tapvpwrvgnd_1
X_6917_ _7215_/CLK _6917_/D VGND VGND VPWR VPWR _6917_/Q sky130_fd_sc_hd__dfxtp_2
XFILLER_23_620 VGND VGND VPWR VPWR sky130_fd_sc_hd__decap_3
XTAP_TAPCELL_ROW_53_957 VGND VPWR sky130_fd_sc_hd__tapvpwrvgnd_1
XFILLER_23_653 VGND VGND VPWR VPWR sky130_fd_sc_hd__decap_3
X_6848_ _6978_/CLK _6848_/D VGND VGND VPWR VPWR _6848_/Q sky130_fd_sc_hd__dfxtp_2
XFILLER_22_152 VGND VGND VPWR VPWR sky130_fd_sc_hd__fill_1
XFILLER_50_472 VGND VGND VPWR VPWR sky130_fd_sc_hd__decap_3
XFILLER_23_697 VGND VGND VPWR VPWR sky130_fd_sc_hd__decap_3
XTAP_TAPCELL_ROW_33_692 VGND VPWR sky130_fd_sc_hd__tapvpwrvgnd_1
X_6779_ _6926_/CLK _6779_/D VGND VGND VPWR VPWR _6779_/Q sky130_fd_sc_hd__dfxtp_2
XFILLER_109_703 VGND VGND VPWR VPWR sky130_fd_sc_hd__decap_3
XFILLER_6_318 VGND VGND VPWR VPWR sky130_fd_sc_hd__fill_1
XFILLER_2_513 VGND VGND VPWR VPWR sky130_fd_sc_hd__decap_3
XFILLER_117_30 VGND VGND VPWR VPWR sky130_fd_sc_hd__decap_3
XFILLER_123_249 VGND VGND VPWR VPWR sky130_fd_sc_hd__decap_3
XFILLER_89_130 VGND VGND VPWR VPWR sky130_fd_sc_hd__decap_3
XFILLER_77_12 VGND VGND VPWR VPWR sky130_fd_sc_hd__decap_3
XFILLER_2_557 VGND VGND VPWR VPWR sky130_fd_sc_hd__decap_3
XFILLER_117_63 VGND VGND VPWR VPWR sky130_fd_sc_hd__decap_3
XFILLER_77_34 VGND VGND VPWR VPWR sky130_fd_sc_hd__fill_1
XFILLER_77_314 VGND VGND VPWR VPWR sky130_fd_sc_hd__decap_3
XFILLER_117_96 VGND VGND VPWR VPWR sky130_fd_sc_hd__decap_3
XFILLER_104_474 VGND VGND VPWR VPWR sky130_fd_sc_hd__fill_2
XFILLER_92_306 VGND VGND VPWR VPWR sky130_fd_sc_hd__fill_2
XFILLER_46_701 VGND VGND VPWR VPWR sky130_fd_sc_hd__decap_3
XFILLER_92_328 VGND VGND VPWR VPWR sky130_fd_sc_hd__decap_3
XFILLER_85_380 VGND VGND VPWR VPWR sky130_fd_sc_hd__decap_3
XFILLER_46_734 VGND VGND VPWR VPWR sky130_fd_sc_hd__fill_1
XFILLER_45_211 VGND VGND VPWR VPWR sky130_fd_sc_hd__decap_3
Xhold1070 _7238_/Q VGND VGND VPWR VPWR _5179_/A sky130_fd_sc_hd__dlygate4sd3_1
XFILLER_18_436 VGND VGND VPWR VPWR sky130_fd_sc_hd__decap_3
Xhold1081 _7323_/Q VGND VGND VPWR VPWR _4513_/A0 sky130_fd_sc_hd__dlygate4sd3_1
Xhold1092 _7331_/Q VGND VGND VPWR VPWR _4497_/A0 sky130_fd_sc_hd__dlygate4sd3_1
XFILLER_18_469 VGND VGND VPWR VPWR sky130_fd_sc_hd__decap_3
XFILLER_61_715 VGND VGND VPWR VPWR sky130_fd_sc_hd__decap_3
XFILLER_60_203 VGND VGND VPWR VPWR sky130_fd_sc_hd__decap_3
XFILLER_45_277 VGND VGND VPWR VPWR sky130_fd_sc_hd__decap_3
XFILLER_33_417 VGND VGND VPWR VPWR sky130_fd_sc_hd__decap_3
XFILLER_26_480 VGND VGND VPWR VPWR sky130_fd_sc_hd__decap_3
XFILLER_14_631 VGND VGND VPWR VPWR sky130_fd_sc_hd__decap_3
XFILLER_60_247 VGND VGND VPWR VPWR sky130_fd_sc_hd__decap_3
XFILLER_13_130 VGND VGND VPWR VPWR sky130_fd_sc_hd__decap_3
XFILLER_14_675 VGND VGND VPWR VPWR sky130_fd_sc_hd__decap_3
XFILLER_41_494 VGND VGND VPWR VPWR sky130_fd_sc_hd__decap_3
XFILLER_13_185 VGND VGND VPWR VPWR sky130_fd_sc_hd__fill_2
XFILLER_9_145 VGND VGND VPWR VPWR sky130_fd_sc_hd__decap_3
XFILLER_42_81 VGND VGND VPWR VPWR sky130_fd_sc_hd__decap_3
XFILLER_115_706 VGND VGND VPWR VPWR sky130_fd_sc_hd__decap_3
XFILLER_5_340 VGND VGND VPWR VPWR sky130_fd_sc_hd__decap_3
XFILLER_114_227 VGND VGND VPWR VPWR sky130_fd_sc_hd__decap_3
XFILLER_96_601 VGND VGND VPWR VPWR sky130_fd_sc_hd__decap_3
XFILLER_3_20 VGND VGND VPWR VPWR sky130_fd_sc_hd__decap_3
X_4130_ _7235_/Q _4430_/A2 _4430_/B1 _7171_/Q _4129_/X VGND VGND VPWR VPWR _4130_/X
+ sky130_fd_sc_hd__a221o_2
XFILLER_96_634 VGND VGND VPWR VPWR sky130_fd_sc_hd__decap_3
XFILLER_95_111 VGND VGND VPWR VPWR sky130_fd_sc_hd__fill_1
XFILLER_96_645 VGND VGND VPWR VPWR sky130_fd_sc_hd__decap_3
X_4061_ _7244_/Q _4433_/B _4436_/B1 _7180_/Q VGND VGND VPWR VPWR _4061_/X sky130_fd_sc_hd__a22o_2
XFILLER_95_144 VGND VGND VPWR VPWR sky130_fd_sc_hd__decap_3
XFILLER_96_678 VGND VGND VPWR VPWR sky130_fd_sc_hd__decap_3
XFILLER_37_712 VGND VGND VPWR VPWR sky130_fd_sc_hd__decap_3
XFILLER_95_188 VGND VGND VPWR VPWR sky130_fd_sc_hd__decap_3
XFILLER_36_200 VGND VGND VPWR VPWR sky130_fd_sc_hd__decap_3
XFILLER_64_520 VGND VGND VPWR VPWR sky130_fd_sc_hd__decap_3
XFILLER_76_380 VGND VGND VPWR VPWR sky130_fd_sc_hd__decap_3
XTAP_TAPCELL_ROW_108_1668 VGND VPWR sky130_fd_sc_hd__tapvpwrvgnd_1
XFILLER_52_704 VGND VGND VPWR VPWR sky130_fd_sc_hd__decap_3
XFILLER_64_575 VGND VGND VPWR VPWR sky130_fd_sc_hd__decap_3
XFILLER_36_277 VGND VGND VPWR VPWR sky130_fd_sc_hd__decap_3
XFILLER_91_383 VGND VGND VPWR VPWR sky130_fd_sc_hd__decap_3
XFILLER_51_225 VGND VGND VPWR VPWR sky130_fd_sc_hd__fill_2
X_4963_ _4963_/A _4963_/B VGND VGND VPWR VPWR _6994_/D sky130_fd_sc_hd__nor2_2
XTAP_TAPCELL_ROW_121_1835 VGND VPWR sky130_fd_sc_hd__tapvpwrvgnd_1
XTAP_TAPCELL_ROW_121_1846 VGND VPWR sky130_fd_sc_hd__tapvpwrvgnd_1
X_6702_ _7401_/CLK _6702_/D VGND VGND VPWR VPWR _6702_/Q sky130_fd_sc_hd__dfxtp_2
X_3914_ _3923_/A1 _3911_/X _3913_/X _3714_/X VGND VGND VPWR VPWR _3914_/X sky130_fd_sc_hd__a22o_2
XTAP_TAPCELL_ROW_50_916 VGND VPWR sky130_fd_sc_hd__tapvpwrvgnd_1
XFILLER_32_450 VGND VGND VPWR VPWR sky130_fd_sc_hd__decap_3
X_4894_ _4908_/A _4908_/B VGND VGND VPWR VPWR _4909_/B sky130_fd_sc_hd__and2_2
XFILLER_20_601 VGND VGND VPWR VPWR sky130_fd_sc_hd__decap_3
XFILLER_32_483 VGND VGND VPWR VPWR sky130_fd_sc_hd__decap_3
X_6633_ _6633_/A VGND VGND VPWR VPWR _6633_/Y sky130_fd_sc_hd__inv_2
XFILLER_20_634 VGND VGND VPWR VPWR sky130_fd_sc_hd__decap_3
X_3845_ _3845_/A _3845_/B VGND VGND VPWR VPWR _3845_/X sky130_fd_sc_hd__or2_2
XFILLER_20_645 VGND VGND VPWR VPWR sky130_fd_sc_hd__decap_3
XFILLER_22_29 VGND VGND VPWR VPWR sky130_fd_sc_hd__decap_3
XTAP_TAPCELL_ROW_30_651 VGND VPWR sky130_fd_sc_hd__tapvpwrvgnd_1
XFILLER_20_678 VGND VGND VPWR VPWR sky130_fd_sc_hd__decap_3
X_6564_ _6566_/A VGND VGND VPWR VPWR _6564_/Y sky130_fd_sc_hd__inv_2
XTAP_TAPCELL_ROW_30_662 VGND VPWR sky130_fd_sc_hd__tapvpwrvgnd_1
X_3776_ _6727_/Q _3851_/A2 _3651_/Y _6977_/Q VGND VGND VPWR VPWR _3776_/X sky130_fd_sc_hd__a22o_2
XFILLER_118_522 VGND VGND VPWR VPWR sky130_fd_sc_hd__decap_3
XFILLER_118_533 VGND VGND VPWR VPWR sky130_fd_sc_hd__decap_3
X_6495_ _6624_/A VGND VGND VPWR VPWR _6495_/Y sky130_fd_sc_hd__inv_2
XFILLER_118_566 VGND VGND VPWR VPWR sky130_fd_sc_hd__decap_3
XFILLER_106_728 VGND VGND VPWR VPWR sky130_fd_sc_hd__decap_3
XFILLER_121_709 VGND VGND VPWR VPWR sky130_fd_sc_hd__decap_3
Xoutput464 _5658_/B VGND VGND VPWR VPWR alu_result_out[12] sky130_fd_sc_hd__clkdlybuf4s25_1
X_5377_ _5377_/A0 _4822_/X _5383_/S VGND VGND VPWR VPWR _7144_/D sky130_fd_sc_hd__mux2_2
Xoutput475 _5663_/C VGND VGND VPWR VPWR alu_result_out[22] sky130_fd_sc_hd__clkdlybuf4s25_1
XFILLER_120_208 VGND VGND VPWR VPWR sky130_fd_sc_hd__fill_1
Xoutput486 place113/X VGND VGND VPWR VPWR alu_result_out[3] sky130_fd_sc_hd__clkdlybuf4s25_1
XFILLER_87_612 VGND VGND VPWR VPWR sky130_fd_sc_hd__decap_3
Xoutput497 _3525_/B VGND VGND VPWR VPWR instruction_out[14] sky130_fd_sc_hd__clkdlybuf4s25_1
X_7116_ _7406_/CLK _7116_/D _6396_/Y VGND VGND VPWR VPWR _7116_/Q sky130_fd_sc_hd__dfrtp_2
XFILLER_87_623 VGND VGND VPWR VPWR sky130_fd_sc_hd__decap_3
XFILLER_113_260 VGND VGND VPWR VPWR sky130_fd_sc_hd__decap_3
X_4328_ _4362_/A _4362_/B _4362_/C VGND VGND VPWR VPWR _5057_/B sky130_fd_sc_hd__a21boi_2
XFILLER_86_111 VGND VGND VPWR VPWR sky130_fd_sc_hd__decap_3
XFILLER_101_422 VGND VGND VPWR VPWR sky130_fd_sc_hd__decap_3
XFILLER_87_656 VGND VGND VPWR VPWR sky130_fd_sc_hd__decap_3
XFILLER_113_293 VGND VGND VPWR VPWR sky130_fd_sc_hd__decap_3
XFILLER_86_144 VGND VGND VPWR VPWR sky130_fd_sc_hd__fill_2
XFILLER_59_358 VGND VGND VPWR VPWR sky130_fd_sc_hd__fill_1
X_7047_ _7398_/CLK _7047_/D _6327_/Y VGND VGND VPWR VPWR _7047_/Q sky130_fd_sc_hd__dfrtp_2
XFILLER_101_455 VGND VGND VPWR VPWR sky130_fd_sc_hd__decap_3
XFILLER_86_166 VGND VGND VPWR VPWR sky130_fd_sc_hd__fill_1
XFILLER_28_701 VGND VGND VPWR VPWR sky130_fd_sc_hd__decap_3
XFILLER_101_488 VGND VGND VPWR VPWR sky130_fd_sc_hd__decap_3
XFILLER_28_734 VGND VGND VPWR VPWR sky130_fd_sc_hd__fill_1
XFILLER_43_715 VGND VGND VPWR VPWR sky130_fd_sc_hd__decap_3
XTAP_TAPCELL_ROW_38_762 VGND VPWR sky130_fd_sc_hd__tapvpwrvgnd_1
XFILLER_27_266 VGND VGND VPWR VPWR sky130_fd_sc_hd__decap_3
XFILLER_42_203 VGND VGND VPWR VPWR sky130_fd_sc_hd__decap_3
XFILLER_27_299 VGND VGND VPWR VPWR sky130_fd_sc_hd__fill_2
XFILLER_103_87 VGND VGND VPWR VPWR sky130_fd_sc_hd__fill_2
XFILLER_63_47 VGND VGND VPWR VPWR sky130_fd_sc_hd__fill_1
XFILLER_42_269 VGND VGND VPWR VPWR sky130_fd_sc_hd__decap_3
XFILLER_30_409 VGND VGND VPWR VPWR sky130_fd_sc_hd__decap_3
XFILLER_70_589 VGND VGND VPWR VPWR sky130_fd_sc_hd__decap_3
XFILLER_23_461 VGND VGND VPWR VPWR sky130_fd_sc_hd__fill_2
XFILLER_11_612 VGND VGND VPWR VPWR sky130_fd_sc_hd__decap_3
XFILLER_11_623 VGND VGND VPWR VPWR sky130_fd_sc_hd__decap_3
XFILLER_50_280 VGND VGND VPWR VPWR sky130_fd_sc_hd__fill_1
XFILLER_11_656 VGND VGND VPWR VPWR sky130_fd_sc_hd__decap_3
XFILLER_7_638 VGND VGND VPWR VPWR sky130_fd_sc_hd__decap_3
XFILLER_109_555 VGND VGND VPWR VPWR sky130_fd_sc_hd__decap_3
XFILLER_109_588 VGND VGND VPWR VPWR sky130_fd_sc_hd__decap_3
XFILLER_88_11 VGND VGND VPWR VPWR sky130_fd_sc_hd__decap_3
XFILLER_88_66 VGND VGND VPWR VPWR sky130_fd_sc_hd__decap_3
XFILLER_78_601 VGND VGND VPWR VPWR sky130_fd_sc_hd__decap_3
XFILLER_88_88 VGND VGND VPWR VPWR sky130_fd_sc_hd__decap_3
XFILLER_104_260 VGND VGND VPWR VPWR sky130_fd_sc_hd__decap_3
XFILLER_78_634 VGND VGND VPWR VPWR sky130_fd_sc_hd__decap_3
XFILLER_77_111 VGND VGND VPWR VPWR sky130_fd_sc_hd__fill_1
XFILLER_120_731 VGND VGND VPWR VPWR sky130_fd_sc_hd__decap_3
XFILLER_78_645 VGND VGND VPWR VPWR sky130_fd_sc_hd__decap_3
XFILLER_77_122 VGND VGND VPWR VPWR sky130_fd_sc_hd__decap_3
XFILLER_77_144 VGND VGND VPWR VPWR sky130_fd_sc_hd__decap_3
XFILLER_78_678 VGND VGND VPWR VPWR sky130_fd_sc_hd__decap_3
XFILLER_93_615 VGND VGND VPWR VPWR sky130_fd_sc_hd__fill_1
XFILLER_93_626 VGND VGND VPWR VPWR sky130_fd_sc_hd__decap_3
XFILLER_65_317 VGND VGND VPWR VPWR sky130_fd_sc_hd__decap_3
XFILLER_19_712 VGND VGND VPWR VPWR sky130_fd_sc_hd__decap_3
XFILLER_18_200 VGND VGND VPWR VPWR sky130_fd_sc_hd__fill_2
XFILLER_77_199 VGND VGND VPWR VPWR sky130_fd_sc_hd__decap_3
XFILLER_18_211 VGND VGND VPWR VPWR sky130_fd_sc_hd__decap_3
XFILLER_93_659 VGND VGND VPWR VPWR sky130_fd_sc_hd__decap_3
XFILLER_80_309 VGND VGND VPWR VPWR sky130_fd_sc_hd__decap_3
XFILLER_34_704 VGND VGND VPWR VPWR sky130_fd_sc_hd__decap_3
XFILLER_61_501 VGND VGND VPWR VPWR sky130_fd_sc_hd__decap_3
XFILLER_37_92 VGND VGND VPWR VPWR sky130_fd_sc_hd__decap_3
XFILLER_61_523 VGND VGND VPWR VPWR sky130_fd_sc_hd__fill_1
XFILLER_33_225 VGND VGND VPWR VPWR sky130_fd_sc_hd__fill_2
XFILLER_61_545 VGND VGND VPWR VPWR sky130_fd_sc_hd__fill_1
XFILLER_21_409 VGND VGND VPWR VPWR sky130_fd_sc_hd__fill_2
XFILLER_61_578 VGND VGND VPWR VPWR sky130_fd_sc_hd__fill_2
XFILLER_61_589 VGND VGND VPWR VPWR sky130_fd_sc_hd__decap_3
XTAP_TAPCELL_ROW_16_478 VGND VPWR sky130_fd_sc_hd__tapvpwrvgnd_1
X_3630_ _3630_/A _3630_/B VGND VGND VPWR VPWR _3636_/B sky130_fd_sc_hd__and2_2
X_3561_ _5129_/A _3561_/B _5668_/A VGND VGND VPWR VPWR _3561_/X sky130_fd_sc_hd__or3_2
XTAP_TAPCELL_ROW_58_1022 VGND VPWR sky130_fd_sc_hd__tapvpwrvgnd_1
XFILLER_6_660 VGND VGND VPWR VPWR sky130_fd_sc_hd__decap_3
XFILLER_115_503 VGND VGND VPWR VPWR sky130_fd_sc_hd__fill_1
X_5300_ _5300_/A0 _4752_/X _5315_/S VGND VGND VPWR VPWR _7180_/D sky130_fd_sc_hd__mux2_2
XFILLER_115_514 VGND VGND VPWR VPWR sky130_fd_sc_hd__decap_3
X_3492_ _7055_/Q _3558_/B _3487_/X _3491_/X VGND VGND VPWR VPWR _4460_/B sky130_fd_sc_hd__o22a_2
X_6280_ _6462_/A VGND VGND VPWR VPWR _6280_/Y sky130_fd_sc_hd__inv_2
XFILLER_6_693 VGND VGND VPWR VPWR sky130_fd_sc_hd__decap_3
XFILLER_115_547 VGND VGND VPWR VPWR sky130_fd_sc_hd__decap_3
XFILLER_103_709 VGND VGND VPWR VPWR sky130_fd_sc_hd__decap_3
XFILLER_69_612 VGND VGND VPWR VPWR sky130_fd_sc_hd__decap_3
XFILLER_69_623 VGND VGND VPWR VPWR sky130_fd_sc_hd__decap_3
XFILLER_69_656 VGND VGND VPWR VPWR sky130_fd_sc_hd__decap_3
X_4113_ _7364_/Q _4261_/A2 _4112_/X _4347_/C1 VGND VGND VPWR VPWR _4113_/X sky130_fd_sc_hd__a211o_2
XFILLER_96_453 VGND VGND VPWR VPWR sky130_fd_sc_hd__decap_3
XFILLER_68_144 VGND VGND VPWR VPWR sky130_fd_sc_hd__decap_3
X_5093_ _5581_/S _3867_/X _5658_/C _5092_/X _3346_/A VGND VGND VPWR VPWR _5093_/X
+ sky130_fd_sc_hd__o32a_2
XFILLER_84_604 VGND VGND VPWR VPWR sky130_fd_sc_hd__decap_3
XFILLER_96_486 VGND VGND VPWR VPWR sky130_fd_sc_hd__decap_3
XFILLER_56_317 VGND VGND VPWR VPWR sky130_fd_sc_hd__fill_2
XFILLER_84_637 VGND VGND VPWR VPWR sky130_fd_sc_hd__decap_3
XFILLER_83_103 VGND VGND VPWR VPWR sky130_fd_sc_hd__decap_3
XFILLER_110_274 VGND VGND VPWR VPWR sky130_fd_sc_hd__decap_3
X_4044_ _7277_/Q _4431_/A2 _4041_/X _4043_/X VGND VGND VPWR VPWR _4044_/X sky130_fd_sc_hd__a211o_2
XFILLER_84_648 VGND VGND VPWR VPWR sky130_fd_sc_hd__decap_3
XFILLER_83_125 VGND VGND VPWR VPWR sky130_fd_sc_hd__decap_3
XFILLER_37_531 VGND VGND VPWR VPWR sky130_fd_sc_hd__decap_3
XFILLER_83_147 VGND VGND VPWR VPWR sky130_fd_sc_hd__decap_3
XFILLER_83_169 VGND VGND VPWR VPWR sky130_fd_sc_hd__fill_1
XTAP_TAPCELL_ROW_69_1162 VGND VPWR sky130_fd_sc_hd__tapvpwrvgnd_1
XFILLER_25_715 VGND VGND VPWR VPWR sky130_fd_sc_hd__decap_3
XFILLER_52_501 VGND VGND VPWR VPWR sky130_fd_sc_hd__decap_3
XFILLER_92_681 VGND VGND VPWR VPWR sky130_fd_sc_hd__decap_3
XFILLER_37_597 VGND VGND VPWR VPWR sky130_fd_sc_hd__decap_3
XTAP_TAPCELL_ROW_35_721 VGND VPWR sky130_fd_sc_hd__tapvpwrvgnd_1
XFILLER_52_545 VGND VGND VPWR VPWR sky130_fd_sc_hd__decap_3
XFILLER_24_236 VGND VGND VPWR VPWR sky130_fd_sc_hd__decap_3
XFILLER_40_707 VGND VGND VPWR VPWR sky130_fd_sc_hd__decap_3
X_4946_ _4946_/A0 _4945_/X _4979_/S VGND VGND VPWR VPWR _7265_/D sky130_fd_sc_hd__mux2_2
X_4877_ _4832_/A _5663_/C _3753_/X _3346_/A VGND VGND VPWR VPWR _4877_/X sky130_fd_sc_hd__o211a_2
XFILLER_32_291 VGND VGND VPWR VPWR sky130_fd_sc_hd__decap_3
X_6616_ _6616_/A VGND VGND VPWR VPWR _6616_/Y sky130_fd_sc_hd__inv_2
X_3828_ _6926_/Q _3906_/A2 _3913_/A2 _6790_/Q _3827_/X VGND VGND VPWR VPWR _3828_/X
+ sky130_fd_sc_hd__a221o_2
XFILLER_20_464 VGND VGND VPWR VPWR sky130_fd_sc_hd__fill_2
XFILLER_20_475 VGND VGND VPWR VPWR sky130_fd_sc_hd__fill_1
X_6547_ _6680_/A VGND VGND VPWR VPWR _6547_/Y sky130_fd_sc_hd__inv_2
XFILLER_118_341 VGND VGND VPWR VPWR sky130_fd_sc_hd__decap_3
X_3759_ _6797_/Q _3759_/A2 _3759_/B1 _6885_/Q VGND VGND VPWR VPWR _3759_/X sky130_fd_sc_hd__a22o_2
XFILLER_4_619 VGND VGND VPWR VPWR sky130_fd_sc_hd__decap_3
X_6478_ _6544_/A VGND VGND VPWR VPWR _6478_/Y sky130_fd_sc_hd__inv_2
XFILLER_3_129 VGND VGND VPWR VPWR sky130_fd_sc_hd__decap_3
XFILLER_106_536 VGND VGND VPWR VPWR sky130_fd_sc_hd__decap_3
XFILLER_106_569 VGND VGND VPWR VPWR sky130_fd_sc_hd__decap_3
X_5429_ _5429_/A0 _4470_/X _5429_/S VGND VGND VPWR VPWR _7119_/D sky130_fd_sc_hd__mux2_2
XFILLER_121_517 VGND VGND VPWR VPWR sky130_fd_sc_hd__decap_3
XTAP_TAPCELL_ROW_93_1480 VGND VPWR sky130_fd_sc_hd__tapvpwrvgnd_1
XFILLER_58_36 VGND VGND VPWR VPWR sky130_fd_sc_hd__fill_1
XFILLER_102_731 VGND VGND VPWR VPWR sky130_fd_sc_hd__decap_3
XFILLER_87_431 VGND VGND VPWR VPWR sky130_fd_sc_hd__fill_1
XFILLER_75_615 VGND VGND VPWR VPWR sky130_fd_sc_hd__fill_1
XFILLER_75_626 VGND VGND VPWR VPWR sky130_fd_sc_hd__decap_3
XFILLER_47_328 VGND VGND VPWR VPWR sky130_fd_sc_hd__decap_3
XFILLER_59_199 VGND VGND VPWR VPWR sky130_fd_sc_hd__decap_3
XFILLER_114_53 VGND VGND VPWR VPWR sky130_fd_sc_hd__decap_3
XFILLER_75_659 VGND VGND VPWR VPWR sky130_fd_sc_hd__decap_3
XFILLER_74_136 VGND VGND VPWR VPWR sky130_fd_sc_hd__decap_3
XFILLER_74_24 VGND VGND VPWR VPWR sky130_fd_sc_hd__decap_3
XFILLER_74_147 VGND VGND VPWR VPWR sky130_fd_sc_hd__decap_3
XFILLER_90_607 VGND VGND VPWR VPWR sky130_fd_sc_hd__decap_3
XFILLER_28_553 VGND VGND VPWR VPWR sky130_fd_sc_hd__decap_3
XFILLER_62_309 VGND VGND VPWR VPWR sky130_fd_sc_hd__decap_3
XFILLER_16_704 VGND VGND VPWR VPWR sky130_fd_sc_hd__decap_3
XFILLER_43_501 VGND VGND VPWR VPWR sky130_fd_sc_hd__decap_3
XFILLER_28_586 VGND VGND VPWR VPWR sky130_fd_sc_hd__fill_2
XFILLER_15_225 VGND VGND VPWR VPWR sky130_fd_sc_hd__decap_3
XFILLER_82_191 VGND VGND VPWR VPWR sky130_fd_sc_hd__fill_2
XFILLER_70_342 VGND VGND VPWR VPWR sky130_fd_sc_hd__decap_3
XFILLER_15_247 VGND VGND VPWR VPWR sky130_fd_sc_hd__fill_2
XFILLER_43_567 VGND VGND VPWR VPWR sky130_fd_sc_hd__fill_2
XFILLER_31_718 VGND VGND VPWR VPWR sky130_fd_sc_hd__decap_3
XFILLER_90_23 VGND VGND VPWR VPWR sky130_fd_sc_hd__decap_3
XFILLER_31_729 VGND VGND VPWR VPWR sky130_fd_sc_hd__decap_3
XFILLER_70_397 VGND VGND VPWR VPWR sky130_fd_sc_hd__fill_2
XFILLER_30_239 VGND VGND VPWR VPWR sky130_fd_sc_hd__decap_3
XTAP_TAPCELL_ROW_13_437 VGND VPWR sky130_fd_sc_hd__tapvpwrvgnd_1
XFILLER_11_420 VGND VGND VPWR VPWR sky130_fd_sc_hd__decap_3
XFILLER_23_50 VGND VGND VPWR VPWR sky130_fd_sc_hd__decap_3
XFILLER_7_402 VGND VGND VPWR VPWR sky130_fd_sc_hd__decap_3
XFILLER_7_424 VGND VGND VPWR VPWR sky130_fd_sc_hd__decap_3
XFILLER_11_475 VGND VGND VPWR VPWR sky130_fd_sc_hd__fill_1
XTAP_TAPCELL_ROW_96_1509 VGND VPWR sky130_fd_sc_hd__tapvpwrvgnd_1
XFILLER_11_497 VGND VGND VPWR VPWR sky130_fd_sc_hd__decap_3
XFILLER_109_330 VGND VGND VPWR VPWR sky130_fd_sc_hd__decap_3
XFILLER_7_468 VGND VGND VPWR VPWR sky130_fd_sc_hd__fill_2
XFILLER_109_352 VGND VGND VPWR VPWR sky130_fd_sc_hd__fill_2
XFILLER_99_54 VGND VGND VPWR VPWR sky130_fd_sc_hd__fill_2
XFILLER_109_374 VGND VGND VPWR VPWR sky130_fd_sc_hd__decap_3
XFILLER_109_396 VGND VGND VPWR VPWR sky130_fd_sc_hd__decap_3
XFILLER_99_87 VGND VGND VPWR VPWR sky130_fd_sc_hd__fill_1
XFILLER_98_707 VGND VGND VPWR VPWR sky130_fd_sc_hd__decap_3
XFILLER_3_641 VGND VGND VPWR VPWR sky130_fd_sc_hd__decap_3
XFILLER_97_206 VGND VGND VPWR VPWR sky130_fd_sc_hd__decap_3
XFILLER_112_528 VGND VGND VPWR VPWR sky130_fd_sc_hd__decap_3
XFILLER_3_685 VGND VGND VPWR VPWR sky130_fd_sc_hd__decap_3
XFILLER_112_539 VGND VGND VPWR VPWR sky130_fd_sc_hd__decap_3
XFILLER_105_591 VGND VGND VPWR VPWR sky130_fd_sc_hd__decap_3
XFILLER_2_195 VGND VGND VPWR VPWR sky130_fd_sc_hd__fill_1
XFILLER_78_453 VGND VGND VPWR VPWR sky130_fd_sc_hd__decap_3
XFILLER_66_615 VGND VGND VPWR VPWR sky130_fd_sc_hd__decap_3
XFILLER_78_486 VGND VGND VPWR VPWR sky130_fd_sc_hd__decap_3
XFILLER_65_103 VGND VGND VPWR VPWR sky130_fd_sc_hd__decap_3
XFILLER_120_572 VGND VGND VPWR VPWR sky130_fd_sc_hd__decap_3
XFILLER_66_648 VGND VGND VPWR VPWR sky130_fd_sc_hd__decap_3
XFILLER_19_564 VGND VGND VPWR VPWR sky130_fd_sc_hd__decap_3
XFILLER_93_489 VGND VGND VPWR VPWR sky130_fd_sc_hd__decap_3
XFILLER_81_629 VGND VGND VPWR VPWR sky130_fd_sc_hd__decap_3
XFILLER_80_106 VGND VGND VPWR VPWR sky130_fd_sc_hd__decap_3
XFILLER_46_361 VGND VGND VPWR VPWR sky130_fd_sc_hd__decap_3
XFILLER_74_681 VGND VGND VPWR VPWR sky130_fd_sc_hd__decap_3
XFILLER_19_597 VGND VGND VPWR VPWR sky130_fd_sc_hd__decap_3
XTAP_TAPCELL_ROW_105_1627 VGND VPWR sky130_fd_sc_hd__tapvpwrvgnd_1
XFILLER_34_523 VGND VGND VPWR VPWR sky130_fd_sc_hd__decap_3
XTAP_TAPCELL_ROW_105_1638 VGND VPWR sky130_fd_sc_hd__tapvpwrvgnd_1
XFILLER_73_191 VGND VGND VPWR VPWR sky130_fd_sc_hd__decap_3
XFILLER_22_707 VGND VGND VPWR VPWR sky130_fd_sc_hd__decap_3
X_4800_ _7002_/Q _4826_/A _7003_/Q VGND VGND VPWR VPWR _4801_/B sky130_fd_sc_hd__a21oi_2
XFILLER_34_589 VGND VGND VPWR VPWR sky130_fd_sc_hd__decap_3
XFILLER_21_228 VGND VGND VPWR VPWR sky130_fd_sc_hd__decap_3
X_4731_ _4731_/A _4731_/B VGND VGND VPWR VPWR _7007_/D sky130_fd_sc_hd__and2_2
XFILLER_119_105 VGND VGND VPWR VPWR sky130_fd_sc_hd__decap_3
XFILLER_119_116 VGND VGND VPWR VPWR sky130_fd_sc_hd__decap_3
X_4662_ _4969_/B _4457_/X _4660_/X _4811_/C _4040_/Y VGND VGND VPWR VPWR _4662_/Y
+ sky130_fd_sc_hd__a221oi_2
X_6401_ _6635_/A VGND VGND VPWR VPWR _6401_/Y sky130_fd_sc_hd__inv_2
XTAP_TAPCELL_ROW_40_790 VGND VPWR sky130_fd_sc_hd__tapvpwrvgnd_1
X_3613_ _3603_/Y _3606_/X _3612_/X VGND VGND VPWR VPWR _3614_/B sky130_fd_sc_hd__a21oi_2
X_7381_ _7387_/CLK _7381_/D _6661_/Y VGND VGND VPWR VPWR _7381_/Q sky130_fd_sc_hd__dfrtp_2
X_4593_ _4593_/A _4595_/B VGND VGND VPWR VPWR _7284_/D sky130_fd_sc_hd__and2_2
Xhold903 _7062_/Q VGND VGND VPWR VPWR _7062_/D sky130_fd_sc_hd__dlygate4sd3_1
X_6332_ _6649_/A VGND VGND VPWR VPWR _6332_/Y sky130_fd_sc_hd__inv_2
Xhold914 _6692_/Q VGND VGND VPWR VPWR hold914/X sky130_fd_sc_hd__dlygate4sd3_1
XFILLER_115_311 VGND VGND VPWR VPWR sky130_fd_sc_hd__decap_3
X_3544_ _3544_/A _3544_/B VGND VGND VPWR VPWR _3635_/A sky130_fd_sc_hd__nor2_2
Xhold925 _6705_/Q VGND VGND VPWR VPWR hold925/X sky130_fd_sc_hd__dlygate4sd3_1
Xhold936 _7311_/Q VGND VGND VPWR VPWR hold936/X sky130_fd_sc_hd__dlygate4sd3_1
XTAP_TAPCELL_ROW_116_1778 VGND VPWR sky130_fd_sc_hd__tapvpwrvgnd_1
Xhold947 _7048_/Q VGND VGND VPWR VPWR hold947/X sky130_fd_sc_hd__dlygate4sd3_1
Xhold958 _7315_/Q VGND VGND VPWR VPWR _4528_/A sky130_fd_sc_hd__dlygate4sd3_1
XFILLER_89_718 VGND VGND VPWR VPWR sky130_fd_sc_hd__decap_3
X_6263_ _6660_/A VGND VGND VPWR VPWR _6263_/Y sky130_fd_sc_hd__inv_2
Xhold969 _7399_/Q VGND VGND VPWR VPWR hold969/X sky130_fd_sc_hd__dlygate4sd3_1
XFILLER_89_729 VGND VGND VPWR VPWR sky130_fd_sc_hd__decap_3
X_3475_ _7248_/Q _3358_/X _3472_/X _3474_/X VGND VGND VPWR VPWR _3502_/A sky130_fd_sc_hd__a211oi_2
XFILLER_88_206 VGND VGND VPWR VPWR sky130_fd_sc_hd__decap_3
XFILLER_69_442 VGND VGND VPWR VPWR sky130_fd_sc_hd__decap_3
X_5145_ _5145_/A _3500_/Y VGND VGND VPWR VPWR _5145_/X sky130_fd_sc_hd__or2b_2
XFILLER_69_464 VGND VGND VPWR VPWR sky130_fd_sc_hd__decap_3
XFILLER_111_561 VGND VGND VPWR VPWR sky130_fd_sc_hd__decap_3
XFILLER_57_626 VGND VGND VPWR VPWR sky130_fd_sc_hd__decap_3
XFILLER_111_594 VGND VGND VPWR VPWR sky130_fd_sc_hd__decap_3
XFILLER_57_659 VGND VGND VPWR VPWR sky130_fd_sc_hd__decap_3
XFILLER_56_136 VGND VGND VPWR VPWR sky130_fd_sc_hd__decap_3
XFILLER_56_147 VGND VGND VPWR VPWR sky130_fd_sc_hd__fill_1
XFILLER_72_607 VGND VGND VPWR VPWR sky130_fd_sc_hd__decap_3
XFILLER_44_309 VGND VGND VPWR VPWR sky130_fd_sc_hd__decap_3
XFILLER_37_361 VGND VGND VPWR VPWR sky130_fd_sc_hd__decap_3
XTAP_TAPCELL_ROW_48_890 VGND VPWR sky130_fd_sc_hd__tapvpwrvgnd_1
XFILLER_71_139 VGND VGND VPWR VPWR sky130_fd_sc_hd__decap_3
XFILLER_64_180 VGND VGND VPWR VPWR sky130_fd_sc_hd__fill_1
XFILLER_44_27 VGND VGND VPWR VPWR sky130_fd_sc_hd__fill_1
XFILLER_80_640 VGND VGND VPWR VPWR sky130_fd_sc_hd__decap_3
XFILLER_80_651 VGND VGND VPWR VPWR sky130_fd_sc_hd__decap_3
XFILLER_25_567 VGND VGND VPWR VPWR sky130_fd_sc_hd__decap_3
XFILLER_40_504 VGND VGND VPWR VPWR sky130_fd_sc_hd__decap_3
XFILLER_13_718 VGND VGND VPWR VPWR sky130_fd_sc_hd__decap_3
XFILLER_13_729 VGND VGND VPWR VPWR sky130_fd_sc_hd__decap_3
XFILLER_80_684 VGND VGND VPWR VPWR sky130_fd_sc_hd__decap_3
XFILLER_12_228 VGND VGND VPWR VPWR sky130_fd_sc_hd__decap_3
XFILLER_40_548 VGND VGND VPWR VPWR sky130_fd_sc_hd__fill_2
X_4929_ _4908_/B _4928_/Y _4983_/A VGND VGND VPWR VPWR _4929_/Y sky130_fd_sc_hd__o21ai_2
XFILLER_40_559 VGND VGND VPWR VPWR sky130_fd_sc_hd__decap_3
XFILLER_60_26 VGND VGND VPWR VPWR sky130_fd_sc_hd__fill_2
XFILLER_100_88 VGND VGND VPWR VPWR sky130_fd_sc_hd__decap_3
XFILLER_121_6 VGND VGND VPWR VPWR sky130_fd_sc_hd__decap_3
XFILLER_119_650 VGND VGND VPWR VPWR sky130_fd_sc_hd__decap_3
XFILLER_4_416 VGND VGND VPWR VPWR sky130_fd_sc_hd__decap_3
XFILLER_119_694 VGND VGND VPWR VPWR sky130_fd_sc_hd__decap_3
XFILLER_118_160 VGND VGND VPWR VPWR sky130_fd_sc_hd__fill_2
XFILLER_109_42 VGND VGND VPWR VPWR sky130_fd_sc_hd__decap_3
XFILLER_4_449 VGND VGND VPWR VPWR sky130_fd_sc_hd__fill_1
XFILLER_69_24 VGND VGND VPWR VPWR sky130_fd_sc_hd__decap_3
XFILLER_109_97 VGND VGND VPWR VPWR sky130_fd_sc_hd__decap_3
XFILLER_0_611 VGND VGND VPWR VPWR sky130_fd_sc_hd__decap_3
XFILLER_94_209 VGND VGND VPWR VPWR sky130_fd_sc_hd__decap_3
XFILLER_85_12 VGND VGND VPWR VPWR sky130_fd_sc_hd__decap_3
XFILLER_48_615 VGND VGND VPWR VPWR sky130_fd_sc_hd__decap_3
XFILLER_102_572 VGND VGND VPWR VPWR sky130_fd_sc_hd__decap_3
XFILLER_87_272 VGND VGND VPWR VPWR sky130_fd_sc_hd__decap_3
XFILLER_0_699 VGND VGND VPWR VPWR sky130_fd_sc_hd__fill_1
XFILLER_48_648 VGND VGND VPWR VPWR sky130_fd_sc_hd__decap_3
XFILLER_63_607 VGND VGND VPWR VPWR sky130_fd_sc_hd__decap_3
XFILLER_18_50 VGND VGND VPWR VPWR sky130_fd_sc_hd__decap_3
XFILLER_47_169 VGND VGND VPWR VPWR sky130_fd_sc_hd__decap_3
XTAP_TAPCELL_ROW_18_507 VGND VPWR sky130_fd_sc_hd__tapvpwrvgnd_1
XFILLER_63_629 VGND VGND VPWR VPWR sky130_fd_sc_hd__decap_3
XFILLER_56_681 VGND VGND VPWR VPWR sky130_fd_sc_hd__decap_3
XFILLER_18_83 VGND VGND VPWR VPWR sky130_fd_sc_hd__fill_1
XFILLER_71_662 VGND VGND VPWR VPWR sky130_fd_sc_hd__decap_3
XFILLER_16_567 VGND VGND VPWR VPWR sky130_fd_sc_hd__decap_3
XFILLER_71_673 VGND VGND VPWR VPWR sky130_fd_sc_hd__decap_3
XFILLER_70_150 VGND VGND VPWR VPWR sky130_fd_sc_hd__decap_3
XFILLER_43_364 VGND VGND VPWR VPWR sky130_fd_sc_hd__decap_3
XFILLER_16_589 VGND VGND VPWR VPWR sky130_fd_sc_hd__decap_3
XFILLER_70_194 VGND VGND VPWR VPWR sky130_fd_sc_hd__fill_2
XFILLER_86_9 VGND VGND VPWR VPWR sky130_fd_sc_hd__decap_3
XTAP_TAPCELL_ROW_100_1568 VGND VPWR sky130_fd_sc_hd__tapvpwrvgnd_1
XFILLER_8_722 VGND VGND VPWR VPWR sky130_fd_sc_hd__decap_3
XFILLER_7_232 VGND VGND VPWR VPWR sky130_fd_sc_hd__decap_3
XFILLER_117_609 VGND VGND VPWR VPWR sky130_fd_sc_hd__decap_3
XFILLER_112_325 VGND VGND VPWR VPWR sky130_fd_sc_hd__decap_3
XFILLER_98_559 VGND VGND VPWR VPWR sky130_fd_sc_hd__decap_3
XFILLER_112_347 VGND VGND VPWR VPWR sky130_fd_sc_hd__fill_2
XFILLER_94_710 VGND VGND VPWR VPWR sky130_fd_sc_hd__decap_3
XFILLER_78_261 VGND VGND VPWR VPWR sky130_fd_sc_hd__decap_3
XFILLER_39_626 VGND VGND VPWR VPWR sky130_fd_sc_hd__decap_3
XFILLER_39_659 VGND VGND VPWR VPWR sky130_fd_sc_hd__decap_3
XFILLER_120_380 VGND VGND VPWR VPWR sky130_fd_sc_hd__decap_3
XFILLER_93_231 VGND VGND VPWR VPWR sky130_fd_sc_hd__decap_3
XFILLER_66_456 VGND VGND VPWR VPWR sky130_fd_sc_hd__fill_1
XFILLER_54_607 VGND VGND VPWR VPWR sky130_fd_sc_hd__decap_3
XFILLER_38_169 VGND VGND VPWR VPWR sky130_fd_sc_hd__decap_3
XFILLER_26_309 VGND VGND VPWR VPWR sky130_fd_sc_hd__decap_3
X_6950_ _6960_/CLK _6950_/D VGND VGND VPWR VPWR _6950_/Q sky130_fd_sc_hd__dfxtp_2
XFILLER_81_426 VGND VGND VPWR VPWR sky130_fd_sc_hd__fill_1
XTAP_TAPCELL_ROW_66_1121 VGND VPWR sky130_fd_sc_hd__tapvpwrvgnd_1
X_6881_ _7215_/CLK _6881_/D VGND VGND VPWR VPWR _6881_/Q sky130_fd_sc_hd__dfxtp_2
XFILLER_46_191 VGND VGND VPWR VPWR sky130_fd_sc_hd__decap_3
XFILLER_62_651 VGND VGND VPWR VPWR sky130_fd_sc_hd__decap_3
XFILLER_61_150 VGND VGND VPWR VPWR sky130_fd_sc_hd__fill_1
XFILLER_62_684 VGND VGND VPWR VPWR sky130_fd_sc_hd__decap_3
XFILLER_61_172 VGND VGND VPWR VPWR sky130_fd_sc_hd__decap_3
XFILLER_34_397 VGND VGND VPWR VPWR sky130_fd_sc_hd__fill_2
XFILLER_61_194 VGND VGND VPWR VPWR sky130_fd_sc_hd__decap_3
XFILLER_22_548 VGND VGND VPWR VPWR sky130_fd_sc_hd__decap_3
XTAP_TAPCELL_ROW_118_1807 VGND VPWR sky130_fd_sc_hd__tapvpwrvgnd_1
XFILLER_30_581 VGND VGND VPWR VPWR sky130_fd_sc_hd__decap_3
XFILLER_30_592 VGND VGND VPWR VPWR sky130_fd_sc_hd__decap_3
X_4645_ _4633_/X _4903_/B _4644_/X _4096_/A VGND VGND VPWR VPWR _4646_/B sky130_fd_sc_hd__o211a_2
XFILLER_107_119 VGND VGND VPWR VPWR sky130_fd_sc_hd__decap_3
Xhold700 _6887_/Q VGND VGND VPWR VPWR _6887_/D sky130_fd_sc_hd__dlygate4sd3_1
X_7364_ _7365_/CLK _7364_/D _6644_/Y VGND VGND VPWR VPWR _7364_/Q sky130_fd_sc_hd__dfrtp_2
Xhold711 _6822_/Q VGND VGND VPWR VPWR _6822_/D sky130_fd_sc_hd__dlygate4sd3_1
XFILLER_116_631 VGND VGND VPWR VPWR sky130_fd_sc_hd__decap_3
Xhold722 _6740_/Q VGND VGND VPWR VPWR _6740_/D sky130_fd_sc_hd__dlygate4sd3_1
Xhold733 _6829_/Q VGND VGND VPWR VPWR _6829_/D sky130_fd_sc_hd__dlygate4sd3_1
XTAP_TAPCELL_ROW_77_1272 VGND VPWR sky130_fd_sc_hd__tapvpwrvgnd_1
X_6315_ _6591_/A VGND VGND VPWR VPWR _6315_/Y sky130_fd_sc_hd__inv_2
Xhold744 _6883_/Q VGND VGND VPWR VPWR _6883_/D sky130_fd_sc_hd__dlygate4sd3_1
X_3527_ _3527_/A _3427_/B VGND VGND VPWR VPWR _4614_/A sky130_fd_sc_hd__nor2b_2
Xhold755 _6757_/Q VGND VGND VPWR VPWR _6757_/D sky130_fd_sc_hd__dlygate4sd3_1
XFILLER_116_675 VGND VGND VPWR VPWR sky130_fd_sc_hd__decap_3
X_7295_ _7359_/CLK _7295_/D _6575_/Y VGND VGND VPWR VPWR _7295_/Q sky130_fd_sc_hd__dfrtp_2
Xhold766 _6754_/Q VGND VGND VPWR VPWR _6754_/D sky130_fd_sc_hd__dlygate4sd3_1
Xhold777 _6753_/Q VGND VGND VPWR VPWR _6753_/D sky130_fd_sc_hd__dlygate4sd3_1
Xhold788 _6793_/Q VGND VGND VPWR VPWR _6793_/D sky130_fd_sc_hd__dlygate4sd3_1
Xhold799 _6901_/Q VGND VGND VPWR VPWR _6901_/D sky130_fd_sc_hd__dlygate4sd3_1
X_3458_ _3544_/A _3506_/B VGND VGND VPWR VPWR _3458_/Y sky130_fd_sc_hd__nor2_2
XFILLER_89_559 VGND VGND VPWR VPWR sky130_fd_sc_hd__fill_1
XFILLER_97_570 VGND VGND VPWR VPWR sky130_fd_sc_hd__decap_3
XFILLER_69_261 VGND VGND VPWR VPWR sky130_fd_sc_hd__decap_3
X_3389_ _7347_/Q _4278_/B1 _3384_/X _3556_/A VGND VGND VPWR VPWR _3389_/X sky130_fd_sc_hd__a211o_2
XFILLER_85_721 VGND VGND VPWR VPWR sky130_fd_sc_hd__decap_3
XFILLER_85_732 VGND VGND VPWR VPWR sky130_fd_sc_hd__decap_3
X_5128_ _3733_/C _3904_/Y _4677_/B VGND VGND VPWR VPWR _5128_/Y sky130_fd_sc_hd__a21oi_2
XFILLER_84_220 VGND VGND VPWR VPWR sky130_fd_sc_hd__decap_3
XFILLER_57_445 VGND VGND VPWR VPWR sky130_fd_sc_hd__decap_3
XFILLER_111_391 VGND VGND VPWR VPWR sky130_fd_sc_hd__fill_1
XFILLER_45_607 VGND VGND VPWR VPWR sky130_fd_sc_hd__decap_3
XFILLER_84_253 VGND VGND VPWR VPWR sky130_fd_sc_hd__decap_3
XFILLER_29_169 VGND VGND VPWR VPWR sky130_fd_sc_hd__fill_2
X_5059_ _3904_/A _3859_/X _5662_/B VGND VGND VPWR VPWR _5059_/X sky130_fd_sc_hd__a21o_2
XFILLER_57_489 VGND VGND VPWR VPWR sky130_fd_sc_hd__decap_3
XFILLER_45_629 VGND VGND VPWR VPWR sky130_fd_sc_hd__decap_3
XFILLER_38_681 VGND VGND VPWR VPWR sky130_fd_sc_hd__decap_3
XFILLER_111_21 VGND VGND VPWR VPWR sky130_fd_sc_hd__decap_3
XFILLER_53_662 VGND VGND VPWR VPWR sky130_fd_sc_hd__decap_3
XFILLER_25_353 VGND VGND VPWR VPWR sky130_fd_sc_hd__decap_3
XFILLER_53_673 VGND VGND VPWR VPWR sky130_fd_sc_hd__decap_3
XFILLER_111_54 VGND VGND VPWR VPWR sky130_fd_sc_hd__fill_2
XFILLER_40_312 VGND VGND VPWR VPWR sky130_fd_sc_hd__decap_3
XFILLER_71_36 VGND VGND VPWR VPWR sky130_fd_sc_hd__fill_1
XFILLER_13_548 VGND VGND VPWR VPWR sky130_fd_sc_hd__decap_3
XFILLER_40_345 VGND VGND VPWR VPWR sky130_fd_sc_hd__decap_3
XTAP_TAPCELL_ROW_23_565 VGND VPWR sky130_fd_sc_hd__tapvpwrvgnd_1
XPHY_EDGE_ROW_109_Right_109 VGND VGND VPWR VPWR sky130_fd_sc_hd__decap_3
XFILLER_40_389 VGND VGND VPWR VPWR sky130_fd_sc_hd__decap_3
XFILLER_21_592 VGND VGND VPWR VPWR sky130_fd_sc_hd__decap_3
XFILLER_5_703 VGND VGND VPWR VPWR sky130_fd_sc_hd__decap_3
XFILLER_107_620 VGND VGND VPWR VPWR sky130_fd_sc_hd__decap_3
XFILLER_107_653 VGND VGND VPWR VPWR sky130_fd_sc_hd__decap_3
XFILLER_122_601 VGND VGND VPWR VPWR sky130_fd_sc_hd__decap_3
XFILLER_107_697 VGND VGND VPWR VPWR sky130_fd_sc_hd__decap_3
XFILLER_122_634 VGND VGND VPWR VPWR sky130_fd_sc_hd__decap_3
XFILLER_121_111 VGND VGND VPWR VPWR sky130_fd_sc_hd__fill_1
XFILLER_122_645 VGND VGND VPWR VPWR sky130_fd_sc_hd__decap_3
XFILLER_121_122 VGND VGND VPWR VPWR sky130_fd_sc_hd__decap_3
XFILLER_122_678 VGND VGND VPWR VPWR sky130_fd_sc_hd__decap_3
XFILLER_0_452 VGND VGND VPWR VPWR sky130_fd_sc_hd__fill_1
XFILLER_96_77 VGND VGND VPWR VPWR sky130_fd_sc_hd__decap_3
XFILLER_76_710 VGND VGND VPWR VPWR sky130_fd_sc_hd__decap_3
XFILLER_48_412 VGND VGND VPWR VPWR sky130_fd_sc_hd__fill_1
XFILLER_0_485 VGND VGND VPWR VPWR sky130_fd_sc_hd__decap_3
XFILLER_88_592 VGND VGND VPWR VPWR sky130_fd_sc_hd__decap_3
XFILLER_102_380 VGND VGND VPWR VPWR sky130_fd_sc_hd__decap_3
XFILLER_75_220 VGND VGND VPWR VPWR sky130_fd_sc_hd__decap_3
XFILLER_29_82 VGND VGND VPWR VPWR sky130_fd_sc_hd__decap_3
XFILLER_75_242 VGND VGND VPWR VPWR sky130_fd_sc_hd__decap_3
XFILLER_36_607 VGND VGND VPWR VPWR sky130_fd_sc_hd__decap_3
XFILLER_75_264 VGND VGND VPWR VPWR sky130_fd_sc_hd__decap_3
XFILLER_91_724 VGND VGND VPWR VPWR sky130_fd_sc_hd__decap_3
Xplace404 _4244_/B VGND VGND VPWR VPWR _4497_/S sky130_fd_sc_hd__buf_2
XFILLER_90_223 VGND VGND VPWR VPWR sky130_fd_sc_hd__decap_3
XFILLER_63_437 VGND VGND VPWR VPWR sky130_fd_sc_hd__fill_2
Xplace415 _4419_/B1 VGND VGND VPWR VPWR _4399_/A2 sky130_fd_sc_hd__buf_2
Xplace426 _3958_/S VGND VGND VPWR VPWR _3943_/S sky130_fd_sc_hd__buf_2
XFILLER_90_245 VGND VGND VPWR VPWR sky130_fd_sc_hd__decap_3
XFILLER_28_191 VGND VGND VPWR VPWR sky130_fd_sc_hd__decap_3
Xplace437 _5156_/S VGND VGND VPWR VPWR _5040_/S sky130_fd_sc_hd__buf_2
XFILLER_90_256 VGND VGND VPWR VPWR sky130_fd_sc_hd__decap_3
XFILLER_44_651 VGND VGND VPWR VPWR sky130_fd_sc_hd__decap_3
XFILLER_16_342 VGND VGND VPWR VPWR sky130_fd_sc_hd__fill_1
Xplace448 _3332_/B VGND VGND VPWR VPWR _4307_/A2 sky130_fd_sc_hd__buf_2
Xplace459 _6979_/Q VGND VGND VPWR VPWR _5667_/A sky130_fd_sc_hd__buf_4
XFILLER_90_278 VGND VGND VPWR VPWR sky130_fd_sc_hd__decap_3
XFILLER_45_70 VGND VGND VPWR VPWR sky130_fd_sc_hd__decap_3
XFILLER_44_684 VGND VGND VPWR VPWR sky130_fd_sc_hd__decap_3
XFILLER_31_323 VGND VGND VPWR VPWR sky130_fd_sc_hd__decap_3
XFILLER_16_397 VGND VGND VPWR VPWR sky130_fd_sc_hd__fill_1
XTAP_TAPCELL_ROW_61_1062 VGND VPWR sky130_fd_sc_hd__tapvpwrvgnd_1
XFILLER_12_592 VGND VGND VPWR VPWR sky130_fd_sc_hd__decap_3
XFILLER_8_563 VGND VGND VPWR VPWR sky130_fd_sc_hd__decap_3
X_4430_ _7239_/Q _4430_/A2 _4430_/B1 _7175_/Q _4429_/X VGND VGND VPWR VPWR _4430_/X
+ sky130_fd_sc_hd__a221o_2
XANTENNA_2 _5658_/D VGND VGND VPWR VPWR sky130_fd_sc_hd__diode_2
X_4361_ _4361_/A _4619_/B _5101_/B _5073_/A VGND VGND VPWR VPWR _4361_/X sky130_fd_sc_hd__and4_2
XTAP_TAPCELL_ROW_113_1737 VGND VPWR sky130_fd_sc_hd__tapvpwrvgnd_1
XFILLER_113_612 VGND VGND VPWR VPWR sky130_fd_sc_hd__decap_3
XFILLER_98_312 VGND VGND VPWR VPWR sky130_fd_sc_hd__decap_3
XFILLER_113_623 VGND VGND VPWR VPWR sky130_fd_sc_hd__decap_3
X_3312_ _5129_/A _4467_/A _3519_/B _3310_/Y _5671_/A VGND VGND VPWR VPWR _5646_/A
+ sky130_fd_sc_hd__a311o_2
X_7080_ _7404_/CLK _7080_/D _6360_/Y VGND VGND VPWR VPWR _7080_/Q sky130_fd_sc_hd__dfrtp_2
X_4292_ _4292_/A _4292_/B _4292_/C VGND VGND VPWR VPWR _4292_/X sky130_fd_sc_hd__and3_2
XFILLER_113_656 VGND VGND VPWR VPWR sky130_fd_sc_hd__decap_3
XFILLER_3_290 VGND VGND VPWR VPWR sky130_fd_sc_hd__decap_3
XFILLER_86_507 VGND VGND VPWR VPWR sky130_fd_sc_hd__decap_3
XFILLER_98_378 VGND VGND VPWR VPWR sky130_fd_sc_hd__decap_3
XFILLER_100_306 VGND VGND VPWR VPWR sky130_fd_sc_hd__fill_2
XFILLER_112_177 VGND VGND VPWR VPWR sky130_fd_sc_hd__decap_3
XFILLER_100_317 VGND VGND VPWR VPWR sky130_fd_sc_hd__fill_1
XFILLER_67_721 VGND VGND VPWR VPWR sky130_fd_sc_hd__decap_3
XFILLER_100_328 VGND VGND VPWR VPWR sky130_fd_sc_hd__decap_3
XFILLER_67_732 VGND VGND VPWR VPWR sky130_fd_sc_hd__decap_3
XFILLER_66_231 VGND VGND VPWR VPWR sky130_fd_sc_hd__decap_3
XFILLER_39_445 VGND VGND VPWR VPWR sky130_fd_sc_hd__decap_3
XFILLER_94_562 VGND VGND VPWR VPWR sky130_fd_sc_hd__decap_3
XFILLER_66_253 VGND VGND VPWR VPWR sky130_fd_sc_hd__decap_3
XFILLER_82_713 VGND VGND VPWR VPWR sky130_fd_sc_hd__decap_3
XFILLER_27_629 VGND VGND VPWR VPWR sky130_fd_sc_hd__decap_3
XFILLER_39_489 VGND VGND VPWR VPWR sky130_fd_sc_hd__decap_3
XFILLER_94_595 VGND VGND VPWR VPWR sky130_fd_sc_hd__decap_3
XFILLER_66_286 VGND VGND VPWR VPWR sky130_fd_sc_hd__decap_3
XFILLER_26_117 VGND VGND VPWR VPWR sky130_fd_sc_hd__decap_3
XFILLER_81_223 VGND VGND VPWR VPWR sky130_fd_sc_hd__fill_1
XFILLER_26_139 VGND VGND VPWR VPWR sky130_fd_sc_hd__fill_1
X_6933_ _7405_/CLK _6933_/D VGND VGND VPWR VPWR _6933_/Q sky130_fd_sc_hd__dfxtp_2
XFILLER_81_234 VGND VGND VPWR VPWR sky130_fd_sc_hd__decap_3
XFILLER_35_662 VGND VGND VPWR VPWR sky130_fd_sc_hd__decap_3
XFILLER_81_278 VGND VGND VPWR VPWR sky130_fd_sc_hd__fill_2
XFILLER_35_673 VGND VGND VPWR VPWR sky130_fd_sc_hd__decap_3
X_6864_ _6965_/CLK _6864_/D VGND VGND VPWR VPWR _6864_/Q sky130_fd_sc_hd__dfxtp_2
XFILLER_50_610 VGND VGND VPWR VPWR sky130_fd_sc_hd__decap_3
XFILLER_22_312 VGND VGND VPWR VPWR sky130_fd_sc_hd__fill_1
XFILLER_34_183 VGND VGND VPWR VPWR sky130_fd_sc_hd__decap_3
XFILLER_50_643 VGND VGND VPWR VPWR sky130_fd_sc_hd__fill_1
XFILLER_22_334 VGND VGND VPWR VPWR sky130_fd_sc_hd__decap_3
XFILLER_50_654 VGND VGND VPWR VPWR sky130_fd_sc_hd__decap_3
X_6795_ _6942_/CLK _6795_/D VGND VGND VPWR VPWR _6795_/Q sky130_fd_sc_hd__dfxtp_2
XFILLER_10_507 VGND VGND VPWR VPWR sky130_fd_sc_hd__decap_3
XFILLER_50_687 VGND VGND VPWR VPWR sky130_fd_sc_hd__decap_3
XFILLER_10_529 VGND VGND VPWR VPWR sky130_fd_sc_hd__decap_3
XFILLER_41_28 VGND VGND VPWR VPWR sky130_fd_sc_hd__decap_3
XTAP_TAPCELL_ROW_20_524 VGND VPWR sky130_fd_sc_hd__tapvpwrvgnd_1
XFILLER_108_417 VGND VGND VPWR VPWR sky130_fd_sc_hd__decap_3
X_4628_ _4628_/A VGND VGND VPWR VPWR _4629_/A sky130_fd_sc_hd__inv_2
XFILLER_116_450 VGND VGND VPWR VPWR sky130_fd_sc_hd__fill_1
X_7347_ _7352_/CLK _7347_/D _6627_/Y VGND VGND VPWR VPWR _7347_/Q sky130_fd_sc_hd__dfrtp_2
XFILLER_104_601 VGND VGND VPWR VPWR sky130_fd_sc_hd__decap_3
X_4559_ _4559_/A _4559_/B VGND VGND VPWR VPWR _7301_/D sky130_fd_sc_hd__and2_2
XFILLER_2_728 VGND VGND VPWR VPWR sky130_fd_sc_hd__decap_3
XFILLER_116_472 VGND VGND VPWR VPWR sky130_fd_sc_hd__decap_3
XFILLER_116_494 VGND VGND VPWR VPWR sky130_fd_sc_hd__decap_3
XFILLER_104_634 VGND VGND VPWR VPWR sky130_fd_sc_hd__decap_3
XFILLER_104_645 VGND VGND VPWR VPWR sky130_fd_sc_hd__decap_3
Xhold585 _6864_/Q VGND VGND VPWR VPWR _6864_/D sky130_fd_sc_hd__dlygate4sd3_1
X_7278_ _7370_/CLK _7278_/D _6558_/Y VGND VGND VPWR VPWR _7278_/Q sky130_fd_sc_hd__dfrtp_2
Xhold596 _6796_/Q VGND VGND VPWR VPWR _6796_/D sky130_fd_sc_hd__dlygate4sd3_1
XFILLER_1_249 VGND VGND VPWR VPWR sky130_fd_sc_hd__decap_3
XFILLER_103_133 VGND VGND VPWR VPWR sky130_fd_sc_hd__decap_3
XFILLER_106_21 VGND VGND VPWR VPWR sky130_fd_sc_hd__decap_3
XFILLER_106_32 VGND VGND VPWR VPWR sky130_fd_sc_hd__decap_3
XFILLER_104_678 VGND VGND VPWR VPWR sky130_fd_sc_hd__decap_3
XFILLER_58_710 VGND VGND VPWR VPWR sky130_fd_sc_hd__decap_3
XFILLER_57_231 VGND VGND VPWR VPWR sky130_fd_sc_hd__decap_3
XFILLER_66_58 VGND VGND VPWR VPWR sky130_fd_sc_hd__decap_3
XFILLER_18_607 VGND VGND VPWR VPWR sky130_fd_sc_hd__decap_3
XFILLER_85_573 VGND VGND VPWR VPWR sky130_fd_sc_hd__decap_3
XFILLER_73_724 VGND VGND VPWR VPWR sky130_fd_sc_hd__decap_3
XFILLER_57_275 VGND VGND VPWR VPWR sky130_fd_sc_hd__decap_3
XFILLER_122_20 VGND VGND VPWR VPWR sky130_fd_sc_hd__decap_3
XFILLER_57_297 VGND VGND VPWR VPWR sky130_fd_sc_hd__decap_3
XTAP_TAPCELL_ROW_28_635 VGND VPWR sky130_fd_sc_hd__tapvpwrvgnd_1
XFILLER_122_53 VGND VGND VPWR VPWR sky130_fd_sc_hd__decap_3
XFILLER_72_245 VGND VGND VPWR VPWR sky130_fd_sc_hd__fill_2
XFILLER_26_640 VGND VGND VPWR VPWR sky130_fd_sc_hd__decap_3
XFILLER_82_24 VGND VGND VPWR VPWR sky130_fd_sc_hd__decap_3
XFILLER_26_651 VGND VGND VPWR VPWR sky130_fd_sc_hd__decap_3
XTAP_TAPCELL_ROW_0_260 VGND VPWR sky130_fd_sc_hd__tapvpwrvgnd_1
XFILLER_82_35 VGND VGND VPWR VPWR sky130_fd_sc_hd__decap_3
XFILLER_60_407 VGND VGND VPWR VPWR sky130_fd_sc_hd__decap_3
XTAP_TAPCELL_ROW_0_271 VGND VPWR sky130_fd_sc_hd__tapvpwrvgnd_1
XFILLER_122_97 VGND VGND VPWR VPWR sky130_fd_sc_hd__decap_3
XTAP_TAPCELL_ROW_56_999 VGND VPWR sky130_fd_sc_hd__tapvpwrvgnd_1
XFILLER_26_684 VGND VGND VPWR VPWR sky130_fd_sc_hd__decap_3
XFILLER_53_470 VGND VGND VPWR VPWR sky130_fd_sc_hd__decap_3
XFILLER_41_610 VGND VGND VPWR VPWR sky130_fd_sc_hd__decap_3
XFILLER_41_632 VGND VGND VPWR VPWR sky130_fd_sc_hd__decap_3
XFILLER_25_194 VGND VGND VPWR VPWR sky130_fd_sc_hd__decap_3
XFILLER_15_51 VGND VGND VPWR VPWR sky130_fd_sc_hd__decap_3
XFILLER_41_665 VGND VGND VPWR VPWR sky130_fd_sc_hd__decap_3
XFILLER_13_356 VGND VGND VPWR VPWR sky130_fd_sc_hd__decap_3
XFILLER_9_316 VGND VGND VPWR VPWR sky130_fd_sc_hd__decap_3
XFILLER_41_676 VGND VGND VPWR VPWR sky130_fd_sc_hd__decap_3
XFILLER_9_327 VGND VGND VPWR VPWR sky130_fd_sc_hd__fill_1
XFILLER_5_555 VGND VGND VPWR VPWR sky130_fd_sc_hd__decap_3
XFILLER_5_588 VGND VGND VPWR VPWR sky130_fd_sc_hd__decap_3
XFILLER_107_472 VGND VGND VPWR VPWR sky130_fd_sc_hd__decap_3
XFILLER_107_494 VGND VGND VPWR VPWR sky130_fd_sc_hd__decap_3
XFILLER_122_453 VGND VGND VPWR VPWR sky130_fd_sc_hd__decap_3
XFILLER_110_604 VGND VGND VPWR VPWR sky130_fd_sc_hd__decap_3
XTAP_TAPCELL_ROW_8_371 VGND VPWR sky130_fd_sc_hd__tapvpwrvgnd_1
XFILLER_95_304 VGND VGND VPWR VPWR sky130_fd_sc_hd__decap_3
XFILLER_68_529 VGND VGND VPWR VPWR sky130_fd_sc_hd__decap_3
XFILLER_122_486 VGND VGND VPWR VPWR sky130_fd_sc_hd__decap_3
XFILLER_49_721 VGND VGND VPWR VPWR sky130_fd_sc_hd__decap_3
XFILLER_110_637 VGND VGND VPWR VPWR sky130_fd_sc_hd__decap_3
XFILLER_95_337 VGND VGND VPWR VPWR sky130_fd_sc_hd__decap_3
XFILLER_49_732 VGND VGND VPWR VPWR sky130_fd_sc_hd__decap_3
XFILLER_110_648 VGND VGND VPWR VPWR sky130_fd_sc_hd__decap_3
XFILLER_0_293 VGND VGND VPWR VPWR sky130_fd_sc_hd__decap_3
XFILLER_48_253 VGND VGND VPWR VPWR sky130_fd_sc_hd__decap_3
XFILLER_64_713 VGND VGND VPWR VPWR sky130_fd_sc_hd__decap_3
XFILLER_36_404 VGND VGND VPWR VPWR sky130_fd_sc_hd__decap_3
XFILLER_36_415 VGND VGND VPWR VPWR sky130_fd_sc_hd__decap_3
XFILLER_76_595 VGND VGND VPWR VPWR sky130_fd_sc_hd__decap_3
XFILLER_63_223 VGND VGND VPWR VPWR sky130_fd_sc_hd__fill_1
XFILLER_48_297 VGND VGND VPWR VPWR sky130_fd_sc_hd__decap_3
XFILLER_91_576 VGND VGND VPWR VPWR sky130_fd_sc_hd__decap_3
XFILLER_63_267 VGND VGND VPWR VPWR sky130_fd_sc_hd__decap_3
XFILLER_17_662 VGND VGND VPWR VPWR sky130_fd_sc_hd__decap_3
XFILLER_63_278 VGND VGND VPWR VPWR sky130_fd_sc_hd__fill_2
XFILLER_51_429 VGND VGND VPWR VPWR sky130_fd_sc_hd__decap_3
XFILLER_17_673 VGND VGND VPWR VPWR sky130_fd_sc_hd__decap_3
XFILLER_32_610 VGND VGND VPWR VPWR sky130_fd_sc_hd__decap_3
XFILLER_16_161 VGND VGND VPWR VPWR sky130_fd_sc_hd__decap_3
Xplace267 _4926_/Y VGND VGND VPWR VPWR _5656_/C sky130_fd_sc_hd__buf_2
Xplace278 _3871_/B1 VGND VGND VPWR VPWR _3759_/B1 sky130_fd_sc_hd__buf_2
Xplace289 _3661_/X VGND VGND VPWR VPWR _3851_/A2 sky130_fd_sc_hd__buf_2
XFILLER_32_643 VGND VGND VPWR VPWR sky130_fd_sc_hd__fill_1
XFILLER_16_194 VGND VGND VPWR VPWR sky130_fd_sc_hd__fill_2
XFILLER_32_654 VGND VGND VPWR VPWR sky130_fd_sc_hd__decap_3
X_5600_ _5600_/A _5634_/B VGND VGND VPWR VPWR _7027_/D sky130_fd_sc_hd__and2_2
XFILLER_32_687 VGND VGND VPWR VPWR sky130_fd_sc_hd__decap_3
X_6580_ _6612_/A VGND VGND VPWR VPWR _6580_/Y sky130_fd_sc_hd__inv_2
XFILLER_82_3 VGND VGND VPWR VPWR sky130_fd_sc_hd__decap_3
X_3792_ hold945/X _3857_/A2 _4961_/A VGND VGND VPWR VPWR _7392_/D sky130_fd_sc_hd__a21o_2
XFILLER_118_704 VGND VGND VPWR VPWR sky130_fd_sc_hd__decap_3
XFILLER_117_214 VGND VGND VPWR VPWR sky130_fd_sc_hd__decap_3
XFILLER_8_382 VGND VGND VPWR VPWR sky130_fd_sc_hd__decap_3
XFILLER_117_225 VGND VGND VPWR VPWR sky130_fd_sc_hd__decap_3
X_7201_ _7395_/CLK _7201_/D _6481_/Y VGND VGND VPWR VPWR _7201_/Q sky130_fd_sc_hd__dfrtp_2
X_4413_ _4413_/A VGND VGND VPWR VPWR _4787_/A sky130_fd_sc_hd__inv_2
XTAP_TAPCELL_ROW_74_1231 VGND VPWR sky130_fd_sc_hd__tapvpwrvgnd_1
XFILLER_99_632 VGND VGND VPWR VPWR sky130_fd_sc_hd__decap_3
X_7132_ _7356_/CLK _7132_/D _6412_/Y VGND VGND VPWR VPWR _7132_/Q sky130_fd_sc_hd__dfrtp_2
X_4344_ _4365_/A _4365_/B _4365_/C VGND VGND VPWR VPWR _4345_/B sky130_fd_sc_hd__a21bo_2
XFILLER_99_665 VGND VGND VPWR VPWR sky130_fd_sc_hd__decap_3
XFILLER_99_676 VGND VGND VPWR VPWR sky130_fd_sc_hd__decap_3
X_7063_ _7387_/CLK _7063_/D _6343_/Y VGND VGND VPWR VPWR _7063_/Q sky130_fd_sc_hd__dfrtp_2
XFILLER_101_615 VGND VGND VPWR VPWR sky130_fd_sc_hd__fill_1
X_4275_ _4275_/A _4274_/Y VGND VGND VPWR VPWR _4277_/B sky130_fd_sc_hd__nor2b_2
XFILLER_101_626 VGND VGND VPWR VPWR sky130_fd_sc_hd__decap_3
XFILLER_101_659 VGND VGND VPWR VPWR sky130_fd_sc_hd__decap_3
XFILLER_67_540 VGND VGND VPWR VPWR sky130_fd_sc_hd__fill_2
XFILLER_39_231 VGND VGND VPWR VPWR sky130_fd_sc_hd__decap_3
XFILLER_67_573 VGND VGND VPWR VPWR sky130_fd_sc_hd__decap_3
XFILLER_82_510 VGND VGND VPWR VPWR sky130_fd_sc_hd__fill_1
XFILLER_55_724 VGND VGND VPWR VPWR sky130_fd_sc_hd__decap_3
XFILLER_27_415 VGND VGND VPWR VPWR sky130_fd_sc_hd__decap_3
XFILLER_39_286 VGND VGND VPWR VPWR sky130_fd_sc_hd__decap_3
XFILLER_94_381 VGND VGND VPWR VPWR sky130_fd_sc_hd__fill_2
XFILLER_54_223 VGND VGND VPWR VPWR sky130_fd_sc_hd__decap_3
XFILLER_27_459 VGND VGND VPWR VPWR sky130_fd_sc_hd__decap_3
XFILLER_82_565 VGND VGND VPWR VPWR sky130_fd_sc_hd__decap_3
XFILLER_54_256 VGND VGND VPWR VPWR sky130_fd_sc_hd__decap_3
XFILLER_70_716 VGND VGND VPWR VPWR sky130_fd_sc_hd__decap_3
XFILLER_54_278 VGND VGND VPWR VPWR sky130_fd_sc_hd__decap_3
X_6916_ _6926_/CLK _6916_/D VGND VGND VPWR VPWR _6916_/Q sky130_fd_sc_hd__dfxtp_2
XFILLER_82_598 VGND VGND VPWR VPWR sky130_fd_sc_hd__decap_3
XFILLER_23_610 VGND VGND VPWR VPWR sky130_fd_sc_hd__decap_3
XTAP_TAPCELL_ROW_85_1371 VGND VPWR sky130_fd_sc_hd__tapvpwrvgnd_1
XTAP_TAPCELL_ROW_53_958 VGND VPWR sky130_fd_sc_hd__tapvpwrvgnd_1
XFILLER_23_632 VGND VGND VPWR VPWR sky130_fd_sc_hd__decap_3
X_6847_ _6978_/CLK _6847_/D VGND VGND VPWR VPWR _6847_/Q sky130_fd_sc_hd__dfxtp_2
XFILLER_23_665 VGND VGND VPWR VPWR sky130_fd_sc_hd__decap_3
XFILLER_23_676 VGND VGND VPWR VPWR sky130_fd_sc_hd__decap_3
XFILLER_10_304 VGND VGND VPWR VPWR sky130_fd_sc_hd__fill_1
X_6778_ _7215_/CLK _6778_/D VGND VGND VPWR VPWR _6778_/Q sky130_fd_sc_hd__dfxtp_2
XTAP_TAPCELL_ROW_33_693 VGND VPWR sky130_fd_sc_hd__tapvpwrvgnd_1
XFILLER_10_337 VGND VGND VPWR VPWR sky130_fd_sc_hd__decap_3
X_5729_ _7370_/Q hold928/X _5735_/S VGND VGND VPWR VPWR _6714_/D sky130_fd_sc_hd__mux2_2
XFILLER_109_715 VGND VGND VPWR VPWR sky130_fd_sc_hd__decap_3
XFILLER_108_214 VGND VGND VPWR VPWR sky130_fd_sc_hd__decap_3
XFILLER_123_206 VGND VGND VPWR VPWR sky130_fd_sc_hd__fill_1
XFILLER_2_525 VGND VGND VPWR VPWR sky130_fd_sc_hd__decap_3
XFILLER_2_536 VGND VGND VPWR VPWR sky130_fd_sc_hd__decap_3
XFILLER_117_42 VGND VGND VPWR VPWR sky130_fd_sc_hd__decap_3
XFILLER_116_280 VGND VGND VPWR VPWR sky130_fd_sc_hd__decap_3
XFILLER_104_442 VGND VGND VPWR VPWR sky130_fd_sc_hd__decap_3
XFILLER_77_24 VGND VGND VPWR VPWR sky130_fd_sc_hd__decap_3
XFILLER_2_569 VGND VGND VPWR VPWR sky130_fd_sc_hd__decap_3
XFILLER_117_75 VGND VGND VPWR VPWR sky130_fd_sc_hd__decap_3
XFILLER_89_186 VGND VGND VPWR VPWR sky130_fd_sc_hd__fill_1
XFILLER_77_57 VGND VGND VPWR VPWR sky130_fd_sc_hd__decap_3
XFILLER_77_326 VGND VGND VPWR VPWR sky130_fd_sc_hd__fill_1
XFILLER_104_486 VGND VGND VPWR VPWR sky130_fd_sc_hd__decap_3
XFILLER_77_337 VGND VGND VPWR VPWR sky130_fd_sc_hd__decap_3
XTAP_TAPCELL_ROW_5_330 VGND VPWR sky130_fd_sc_hd__tapvpwrvgnd_1
XFILLER_77_359 VGND VGND VPWR VPWR sky130_fd_sc_hd__decap_3
XFILLER_46_713 VGND VGND VPWR VPWR sky130_fd_sc_hd__decap_3
XFILLER_58_584 VGND VGND VPWR VPWR sky130_fd_sc_hd__decap_3
Xhold1060 _7278_/Q VGND VGND VPWR VPWR _4718_/A0 sky130_fd_sc_hd__dlygate4sd3_1
XFILLER_100_681 VGND VGND VPWR VPWR sky130_fd_sc_hd__decap_3
Xhold1071 _7226_/Q VGND VGND VPWR VPWR _5205_/A sky130_fd_sc_hd__dlygate4sd3_1
XFILLER_45_223 VGND VGND VPWR VPWR sky130_fd_sc_hd__fill_1
Xhold1082 _7333_/Q VGND VGND VPWR VPWR _4493_/A0 sky130_fd_sc_hd__dlygate4sd3_1
XFILLER_45_234 VGND VGND VPWR VPWR sky130_fd_sc_hd__decap_3
XFILLER_18_448 VGND VGND VPWR VPWR sky130_fd_sc_hd__decap_3
Xhold1093 _7301_/Q VGND VGND VPWR VPWR _4559_/A sky130_fd_sc_hd__dlygate4sd3_1
XFILLER_45_256 VGND VGND VPWR VPWR sky130_fd_sc_hd__decap_3
XFILLER_61_727 VGND VGND VPWR VPWR sky130_fd_sc_hd__fill_1
XFILLER_60_215 VGND VGND VPWR VPWR sky130_fd_sc_hd__fill_2
XFILLER_33_429 VGND VGND VPWR VPWR sky130_fd_sc_hd__decap_3
XFILLER_14_610 VGND VGND VPWR VPWR sky130_fd_sc_hd__decap_3
XFILLER_26_83 VGND VGND VPWR VPWR sky130_fd_sc_hd__fill_1
XFILLER_14_643 VGND VGND VPWR VPWR sky130_fd_sc_hd__fill_1
XFILLER_60_259 VGND VGND VPWR VPWR sky130_fd_sc_hd__decap_3
XFILLER_14_654 VGND VGND VPWR VPWR sky130_fd_sc_hd__decap_3
XFILLER_13_142 VGND VGND VPWR VPWR sky130_fd_sc_hd__fill_2
XFILLER_14_687 VGND VGND VPWR VPWR sky130_fd_sc_hd__decap_3
XFILLER_13_164 VGND VGND VPWR VPWR sky130_fd_sc_hd__fill_1
XFILLER_9_113 VGND VGND VPWR VPWR sky130_fd_sc_hd__decap_3
XFILLER_9_179 VGND VGND VPWR VPWR sky130_fd_sc_hd__decap_3
XFILLER_115_718 VGND VGND VPWR VPWR sky130_fd_sc_hd__decap_3
XFILLER_115_729 VGND VGND VPWR VPWR sky130_fd_sc_hd__decap_3
XFILLER_114_206 VGND VGND VPWR VPWR sky130_fd_sc_hd__decap_3
XPHY_EDGE_ROW_39_Left_163 VGND VGND VPWR VPWR sky130_fd_sc_hd__decap_3
XFILLER_96_613 VGND VGND VPWR VPWR sky130_fd_sc_hd__decap_3
XFILLER_3_32 VGND VGND VPWR VPWR sky130_fd_sc_hd__decap_3
XFILLER_122_261 VGND VGND VPWR VPWR sky130_fd_sc_hd__fill_1
XFILLER_95_123 VGND VGND VPWR VPWR sky130_fd_sc_hd__decap_3
XFILLER_68_337 VGND VGND VPWR VPWR sky130_fd_sc_hd__decap_3
XFILLER_96_657 VGND VGND VPWR VPWR sky130_fd_sc_hd__decap_3
XFILLER_1_591 VGND VGND VPWR VPWR sky130_fd_sc_hd__decap_3
X_4060_ _7084_/Q _4102_/B _4432_/B1 _4059_/X VGND VGND VPWR VPWR _4068_/A sky130_fd_sc_hd__o211a_2
XFILLER_49_540 VGND VGND VPWR VPWR sky130_fd_sc_hd__decap_3
XFILLER_95_156 VGND VGND VPWR VPWR sky130_fd_sc_hd__decap_3
XFILLER_49_551 VGND VGND VPWR VPWR sky130_fd_sc_hd__decap_3
XFILLER_83_318 VGND VGND VPWR VPWR sky130_fd_sc_hd__decap_3
XFILLER_37_724 VGND VGND VPWR VPWR sky130_fd_sc_hd__decap_3
XFILLER_36_212 VGND VGND VPWR VPWR sky130_fd_sc_hd__decap_3
XFILLER_36_234 VGND VGND VPWR VPWR sky130_fd_sc_hd__fill_1
XFILLER_91_340 VGND VGND VPWR VPWR sky130_fd_sc_hd__decap_3
XPHY_EDGE_ROW_48_Left_172 VGND VGND VPWR VPWR sky130_fd_sc_hd__decap_3
XTAP_TAPCELL_ROW_108_1669 VGND VPWR sky130_fd_sc_hd__tapvpwrvgnd_1
XFILLER_36_256 VGND VGND VPWR VPWR sky130_fd_sc_hd__decap_3
XFILLER_52_716 VGND VGND VPWR VPWR sky130_fd_sc_hd__decap_3
XFILLER_64_587 VGND VGND VPWR VPWR sky130_fd_sc_hd__fill_1
XFILLER_64_598 VGND VGND VPWR VPWR sky130_fd_sc_hd__decap_3
XFILLER_36_289 VGND VGND VPWR VPWR sky130_fd_sc_hd__decap_3
X_4962_ _6994_/Q _4977_/A VGND VGND VPWR VPWR _4963_/B sky130_fd_sc_hd__nor2_2
XFILLER_17_470 VGND VGND VPWR VPWR sky130_fd_sc_hd__decap_3
XTAP_TAPCELL_ROW_121_1836 VGND VPWR sky130_fd_sc_hd__tapvpwrvgnd_1
X_3913_ _6857_/Q _3913_/A2 _3925_/A2 _6849_/Q _3912_/X VGND VGND VPWR VPWR _3913_/X
+ sky130_fd_sc_hd__a221o_2
X_6701_ _7401_/CLK _6701_/D VGND VGND VPWR VPWR _6701_/Q sky130_fd_sc_hd__dfxtp_2
X_4893_ _4928_/B _4943_/A _6996_/Q VGND VGND VPWR VPWR _4908_/B sky130_fd_sc_hd__o21a_2
XTAP_TAPCELL_ROW_50_917 VGND VPWR sky130_fd_sc_hd__tapvpwrvgnd_1
XFILLER_32_462 VGND VGND VPWR VPWR sky130_fd_sc_hd__decap_3
X_6632_ _6632_/A VGND VGND VPWR VPWR _6632_/Y sky130_fd_sc_hd__inv_2
XFILLER_20_613 VGND VGND VPWR VPWR sky130_fd_sc_hd__decap_3
X_3844_ _3741_/X _3841_/X _3843_/X _3923_/A1 VGND VGND VPWR VPWR _3845_/B sky130_fd_sc_hd__a22o_2
XFILLER_32_495 VGND VGND VPWR VPWR sky130_fd_sc_hd__decap_3
XFILLER_20_657 VGND VGND VPWR VPWR sky130_fd_sc_hd__decap_3
X_6563_ _6566_/A VGND VGND VPWR VPWR _6563_/Y sky130_fd_sc_hd__inv_2
XFILLER_118_501 VGND VGND VPWR VPWR sky130_fd_sc_hd__decap_3
XTAP_TAPCELL_ROW_30_652 VGND VPWR sky130_fd_sc_hd__tapvpwrvgnd_1
X_3775_ _3714_/X _3772_/X _3774_/X _3733_/X VGND VGND VPWR VPWR _3775_/X sky130_fd_sc_hd__a22o_2
XTAP_TAPCELL_ROW_30_663 VGND VPWR sky130_fd_sc_hd__tapvpwrvgnd_1
XFILLER_9_691 VGND VGND VPWR VPWR sky130_fd_sc_hd__decap_3
XFILLER_118_545 VGND VGND VPWR VPWR sky130_fd_sc_hd__decap_3
X_6494_ _6619_/A VGND VGND VPWR VPWR _6494_/Y sky130_fd_sc_hd__inv_2
XPHY_EDGE_ROW_57_Left_181 VGND VGND VPWR VPWR sky130_fd_sc_hd__decap_3
XFILLER_106_707 VGND VGND VPWR VPWR sky130_fd_sc_hd__decap_3
XFILLER_118_578 VGND VGND VPWR VPWR sky130_fd_sc_hd__decap_3
XFILLER_118_589 VGND VGND VPWR VPWR sky130_fd_sc_hd__decap_3
XFILLER_105_228 VGND VGND VPWR VPWR sky130_fd_sc_hd__decap_3
Xoutput465 _5023_/Y VGND VGND VPWR VPWR alu_result_out[13] sky130_fd_sc_hd__clkdlybuf4s25_1
Xoutput476 _5655_/D VGND VGND VPWR VPWR alu_result_out[23] sky130_fd_sc_hd__clkdlybuf4s25_1
Xoutput487 _3735_/A VGND VGND VPWR VPWR alu_result_out[4] sky130_fd_sc_hd__clkdlybuf4s25_1
X_7115_ _7372_/CLK _7115_/D _6395_/Y VGND VGND VPWR VPWR _7115_/Q sky130_fd_sc_hd__dfrtp_2
X_4327_ _4327_/A _4327_/B VGND VGND VPWR VPWR _4362_/C sky130_fd_sc_hd__nand2_2
Xoutput498 _3429_/A VGND VGND VPWR VPWR instruction_out[15] sky130_fd_sc_hd__clkdlybuf4s25_1
XFILLER_87_635 VGND VGND VPWR VPWR sky130_fd_sc_hd__decap_3
XFILLER_113_272 VGND VGND VPWR VPWR sky130_fd_sc_hd__decap_3
XFILLER_59_337 VGND VGND VPWR VPWR sky130_fd_sc_hd__decap_3
XFILLER_101_434 VGND VGND VPWR VPWR sky130_fd_sc_hd__decap_3
X_7046_ _7398_/CLK _7046_/D _6326_/Y VGND VGND VPWR VPWR _7046_/Q sky130_fd_sc_hd__dfrtp_2
XFILLER_87_668 VGND VGND VPWR VPWR sky130_fd_sc_hd__decap_3
X_4258_ _4988_/A _4988_/B VGND VGND VPWR VPWR _5003_/A sky130_fd_sc_hd__or2_4
XFILLER_87_679 VGND VGND VPWR VPWR sky130_fd_sc_hd__decap_3
XFILLER_101_467 VGND VGND VPWR VPWR sky130_fd_sc_hd__decap_3
XFILLER_86_178 VGND VGND VPWR VPWR sky130_fd_sc_hd__decap_3
XFILLER_28_713 VGND VGND VPWR VPWR sky130_fd_sc_hd__decap_3
XTAP_TAPCELL_ROW_87_1400 VGND VPWR sky130_fd_sc_hd__tapvpwrvgnd_1
X_4189_ _7231_/Q _4421_/A2 _4459_/C1 _7167_/Q _4188_/X VGND VGND VPWR VPWR _4189_/X
+ sky130_fd_sc_hd__a221o_2
XFILLER_27_212 VGND VGND VPWR VPWR sky130_fd_sc_hd__decap_3
XPHY_EDGE_ROW_66_Left_190 VGND VGND VPWR VPWR sky130_fd_sc_hd__decap_3
XFILLER_55_543 VGND VGND VPWR VPWR sky130_fd_sc_hd__decap_3
XFILLER_27_234 VGND VGND VPWR VPWR sky130_fd_sc_hd__fill_1
XTAP_TAPCELL_ROW_38_763 VGND VPWR sky130_fd_sc_hd__tapvpwrvgnd_1
XFILLER_55_576 VGND VGND VPWR VPWR sky130_fd_sc_hd__decap_3
XFILLER_103_55 VGND VGND VPWR VPWR sky130_fd_sc_hd__fill_1
XFILLER_43_727 VGND VGND VPWR VPWR sky130_fd_sc_hd__fill_1
XFILLER_27_278 VGND VGND VPWR VPWR sky130_fd_sc_hd__fill_2
XFILLER_63_37 VGND VGND VPWR VPWR sky130_fd_sc_hd__fill_1
XFILLER_42_215 VGND VGND VPWR VPWR sky130_fd_sc_hd__decap_3
XFILLER_42_259 VGND VGND VPWR VPWR sky130_fd_sc_hd__decap_3
XFILLER_23_473 VGND VGND VPWR VPWR sky130_fd_sc_hd__decap_3
XFILLER_11_635 VGND VGND VPWR VPWR sky130_fd_sc_hd__decap_3
XFILLER_50_292 VGND VGND VPWR VPWR sky130_fd_sc_hd__decap_3
XFILLER_7_606 VGND VGND VPWR VPWR sky130_fd_sc_hd__decap_3
XFILLER_7_617 VGND VGND VPWR VPWR sky130_fd_sc_hd__decap_3
XFILLER_11_668 VGND VGND VPWR VPWR sky130_fd_sc_hd__decap_3
XFILLER_11_679 VGND VGND VPWR VPWR sky130_fd_sc_hd__decap_3
XTAP_TAPCELL_ROW_98_1540 VGND VPWR sky130_fd_sc_hd__tapvpwrvgnd_1
XFILLER_109_534 VGND VGND VPWR VPWR sky130_fd_sc_hd__decap_3
XFILLER_109_567 VGND VGND VPWR VPWR sky130_fd_sc_hd__decap_3
XFILLER_88_23 VGND VGND VPWR VPWR sky130_fd_sc_hd__decap_3
XFILLER_2_300 VGND VGND VPWR VPWR sky130_fd_sc_hd__decap_3
XFILLER_111_209 VGND VGND VPWR VPWR sky130_fd_sc_hd__decap_3
XFILLER_78_613 VGND VGND VPWR VPWR sky130_fd_sc_hd__decap_3
XFILLER_120_710 VGND VGND VPWR VPWR sky130_fd_sc_hd__decap_3
XFILLER_78_657 VGND VGND VPWR VPWR sky130_fd_sc_hd__decap_3
XFILLER_77_156 VGND VGND VPWR VPWR sky130_fd_sc_hd__decap_3
XFILLER_77_178 VGND VGND VPWR VPWR sky130_fd_sc_hd__decap_3
XFILLER_93_638 VGND VGND VPWR VPWR sky130_fd_sc_hd__decap_3
XFILLER_19_724 VGND VGND VPWR VPWR sky130_fd_sc_hd__decap_3
XFILLER_86_690 VGND VGND VPWR VPWR sky130_fd_sc_hd__decap_3
XFILLER_18_245 VGND VGND VPWR VPWR sky130_fd_sc_hd__fill_2
XPHY_EDGE_ROW_16_Right_16 VGND VGND VPWR VPWR sky130_fd_sc_hd__decap_3
XFILLER_18_256 VGND VGND VPWR VPWR sky130_fd_sc_hd__fill_1
XFILLER_34_716 VGND VGND VPWR VPWR sky130_fd_sc_hd__decap_3
XFILLER_46_587 VGND VGND VPWR VPWR sky130_fd_sc_hd__fill_1
XFILLER_33_259 VGND VGND VPWR VPWR sky130_fd_sc_hd__decap_3
XTAP_TAPCELL_ROW_16_479 VGND VPWR sky130_fd_sc_hd__tapvpwrvgnd_1
XFILLER_41_281 VGND VGND VPWR VPWR sky130_fd_sc_hd__decap_3
XPHY_EDGE_ROW_25_Right_25 VGND VGND VPWR VPWR sky130_fd_sc_hd__decap_3
X_3560_ _5118_/D _3560_/B VGND VGND VPWR VPWR _3562_/B sky130_fd_sc_hd__nor2_2
XFILLER_10_690 VGND VGND VPWR VPWR sky130_fd_sc_hd__decap_3
XTAP_TAPCELL_ROW_58_1023 VGND VPWR sky130_fd_sc_hd__tapvpwrvgnd_1
XFILLER_6_672 VGND VGND VPWR VPWR sky130_fd_sc_hd__decap_3
X_3491_ _7215_/Q _3377_/X _3366_/X _7151_/Q _3490_/X VGND VGND VPWR VPWR _3491_/X
+ sky130_fd_sc_hd__a221o_2
XFILLER_115_526 VGND VGND VPWR VPWR sky130_fd_sc_hd__decap_3
XFILLER_115_559 VGND VGND VPWR VPWR sky130_fd_sc_hd__fill_1
X_5161_ _5161_/A _5641_/A VGND VGND VPWR VPWR _5225_/B sky130_fd_sc_hd__or2_2
XFILLER_123_570 VGND VGND VPWR VPWR sky130_fd_sc_hd__decap_3
XFILLER_69_635 VGND VGND VPWR VPWR sky130_fd_sc_hd__decap_3
XFILLER_123_581 VGND VGND VPWR VPWR sky130_fd_sc_hd__decap_3
XFILLER_111_721 VGND VGND VPWR VPWR sky130_fd_sc_hd__decap_3
XFILLER_111_732 VGND VGND VPWR VPWR sky130_fd_sc_hd__decap_3
XFILLER_123_592 VGND VGND VPWR VPWR sky130_fd_sc_hd__decap_3
X_4112_ _7332_/Q _3964_/S _4505_/S _7300_/Q VGND VGND VPWR VPWR _4112_/X sky130_fd_sc_hd__a22o_2
XFILLER_69_668 VGND VGND VPWR VPWR sky130_fd_sc_hd__decap_3
X_5092_ _5069_/B _5092_/B _5092_/C VGND VGND VPWR VPWR _5092_/X sky130_fd_sc_hd__and3b_2
XFILLER_69_679 VGND VGND VPWR VPWR sky130_fd_sc_hd__decap_3
XFILLER_110_242 VGND VGND VPWR VPWR sky130_fd_sc_hd__decap_3
XFILLER_96_465 VGND VGND VPWR VPWR sky130_fd_sc_hd__decap_3
XFILLER_84_616 VGND VGND VPWR VPWR sky130_fd_sc_hd__decap_3
XFILLER_110_253 VGND VGND VPWR VPWR sky130_fd_sc_hd__decap_3
X_4043_ _7309_/Q _4488_/S _4430_/B1 _7181_/Q _4042_/X VGND VGND VPWR VPWR _4043_/X
+ sky130_fd_sc_hd__a221o_2
XFILLER_96_498 VGND VGND VPWR VPWR sky130_fd_sc_hd__decap_3
XFILLER_56_329 VGND VGND VPWR VPWR sky130_fd_sc_hd__decap_3
XPHY_EDGE_ROW_34_Right_34 VGND VGND VPWR VPWR sky130_fd_sc_hd__decap_3
XFILLER_49_381 VGND VGND VPWR VPWR sky130_fd_sc_hd__decap_3
XFILLER_37_543 VGND VGND VPWR VPWR sky130_fd_sc_hd__decap_3
XFILLER_83_159 VGND VGND VPWR VPWR sky130_fd_sc_hd__decap_3
XFILLER_92_660 VGND VGND VPWR VPWR sky130_fd_sc_hd__decap_3
XFILLER_64_351 VGND VGND VPWR VPWR sky130_fd_sc_hd__decap_3
XTAP_TAPCELL_ROW_69_1163 VGND VPWR sky130_fd_sc_hd__tapvpwrvgnd_1
XFILLER_52_513 VGND VGND VPWR VPWR sky130_fd_sc_hd__decap_3
XFILLER_25_727 VGND VGND VPWR VPWR sky130_fd_sc_hd__fill_1
XFILLER_92_693 VGND VGND VPWR VPWR sky130_fd_sc_hd__decap_3
XTAP_TAPCELL_ROW_35_722 VGND VPWR sky130_fd_sc_hd__tapvpwrvgnd_1
XFILLER_91_181 VGND VGND VPWR VPWR sky130_fd_sc_hd__decap_3
XFILLER_24_226 VGND VGND VPWR VPWR sky130_fd_sc_hd__decap_3
XFILLER_24_248 VGND VGND VPWR VPWR sky130_fd_sc_hd__decap_3
XTAP_TAPCELL_ROW_82_1330 VGND VPWR sky130_fd_sc_hd__tapvpwrvgnd_1
XFILLER_24_259 VGND VGND VPWR VPWR sky130_fd_sc_hd__decap_3
X_4945_ _5040_/S _6995_/D _5657_/C _4944_/X VGND VGND VPWR VPWR _4945_/X sky130_fd_sc_hd__o22a_2
XFILLER_40_719 VGND VGND VPWR VPWR sky130_fd_sc_hd__decap_3
XFILLER_33_29 VGND VGND VPWR VPWR sky130_fd_sc_hd__decap_3
X_3827_ _6700_/Q _3917_/A2 _3912_/B1 _6878_/Q VGND VGND VPWR VPWR _3827_/X sky130_fd_sc_hd__a22o_2
X_6615_ _6651_/A VGND VGND VPWR VPWR _6615_/Y sky130_fd_sc_hd__inv_2
XPHY_EDGE_ROW_43_Right_43 VGND VGND VPWR VPWR sky130_fd_sc_hd__decap_3
XFILLER_118_320 VGND VGND VPWR VPWR sky130_fd_sc_hd__decap_3
X_6546_ _6643_/A VGND VGND VPWR VPWR _6546_/Y sky130_fd_sc_hd__inv_2
X_6477_ _6542_/A VGND VGND VPWR VPWR _6477_/Y sky130_fd_sc_hd__inv_2
XFILLER_118_386 VGND VGND VPWR VPWR sky130_fd_sc_hd__fill_1
XFILLER_106_526 VGND VGND VPWR VPWR sky130_fd_sc_hd__decap_3
XFILLER_106_548 VGND VGND VPWR VPWR sky130_fd_sc_hd__decap_3
XTAP_TAPCELL_ROW_93_1470 VGND VPWR sky130_fd_sc_hd__tapvpwrvgnd_1
XTAP_TAPCELL_ROW_93_1481 VGND VPWR sky130_fd_sc_hd__tapvpwrvgnd_1
XFILLER_121_529 VGND VGND VPWR VPWR sky130_fd_sc_hd__decap_3
XFILLER_102_710 VGND VGND VPWR VPWR sky130_fd_sc_hd__decap_3
XFILLER_99_281 VGND VGND VPWR VPWR sky130_fd_sc_hd__decap_3
XFILLER_114_581 VGND VGND VPWR VPWR sky130_fd_sc_hd__decap_3
XFILLER_58_48 VGND VGND VPWR VPWR sky130_fd_sc_hd__decap_3
XFILLER_114_592 VGND VGND VPWR VPWR sky130_fd_sc_hd__decap_3
XFILLER_101_231 VGND VGND VPWR VPWR sky130_fd_sc_hd__decap_3
XPHY_EDGE_ROW_52_Right_52 VGND VGND VPWR VPWR sky130_fd_sc_hd__decap_3
XFILLER_87_465 VGND VGND VPWR VPWR sky130_fd_sc_hd__decap_3
XFILLER_114_21 VGND VGND VPWR VPWR sky130_fd_sc_hd__decap_3
XFILLER_114_32 VGND VGND VPWR VPWR sky130_fd_sc_hd__decap_3
X_7029_ _7345_/CLK _7029_/D _6309_/Y VGND VGND VPWR VPWR _7029_/Q sky130_fd_sc_hd__dfrtp_2
XFILLER_75_638 VGND VGND VPWR VPWR sky130_fd_sc_hd__decap_3
XFILLER_68_690 VGND VGND VPWR VPWR sky130_fd_sc_hd__decap_3
XFILLER_114_65 VGND VGND VPWR VPWR sky130_fd_sc_hd__decap_3
XFILLER_74_159 VGND VGND VPWR VPWR sky130_fd_sc_hd__decap_3
XFILLER_55_340 VGND VGND VPWR VPWR sky130_fd_sc_hd__fill_2
XFILLER_90_619 VGND VGND VPWR VPWR sky130_fd_sc_hd__decap_3
XFILLER_28_565 VGND VGND VPWR VPWR sky130_fd_sc_hd__decap_3
XFILLER_16_716 VGND VGND VPWR VPWR sky130_fd_sc_hd__decap_3
XFILLER_83_671 VGND VGND VPWR VPWR sky130_fd_sc_hd__fill_1
XFILLER_83_682 VGND VGND VPWR VPWR sky130_fd_sc_hd__decap_3
XFILLER_15_204 VGND VGND VPWR VPWR sky130_fd_sc_hd__decap_3
XFILLER_28_598 VGND VGND VPWR VPWR sky130_fd_sc_hd__decap_3
XFILLER_70_321 VGND VGND VPWR VPWR sky130_fd_sc_hd__decap_3
XFILLER_43_535 VGND VGND VPWR VPWR sky130_fd_sc_hd__decap_3
XFILLER_70_354 VGND VGND VPWR VPWR sky130_fd_sc_hd__decap_3
XFILLER_15_259 VGND VGND VPWR VPWR sky130_fd_sc_hd__decap_3
XFILLER_70_365 VGND VGND VPWR VPWR sky130_fd_sc_hd__decap_3
XFILLER_30_207 VGND VGND VPWR VPWR sky130_fd_sc_hd__decap_3
XPHY_EDGE_ROW_61_Right_61 VGND VGND VPWR VPWR sky130_fd_sc_hd__decap_3
XTAP_TAPCELL_ROW_13_438 VGND VPWR sky130_fd_sc_hd__tapvpwrvgnd_1
XFILLER_23_281 VGND VGND VPWR VPWR sky130_fd_sc_hd__decap_3
XFILLER_11_432 VGND VGND VPWR VPWR sky130_fd_sc_hd__decap_3
XFILLER_7_414 VGND VGND VPWR VPWR sky130_fd_sc_hd__fill_1
XFILLER_23_84 VGND VGND VPWR VPWR sky130_fd_sc_hd__decap_3
XFILLER_99_66 VGND VGND VPWR VPWR sky130_fd_sc_hd__fill_1
XFILLER_109_386 VGND VGND VPWR VPWR sky130_fd_sc_hd__decap_3
XFILLER_3_620 VGND VGND VPWR VPWR sky130_fd_sc_hd__decap_3
XFILLER_98_719 VGND VGND VPWR VPWR sky130_fd_sc_hd__decap_3
XFILLER_3_653 VGND VGND VPWR VPWR sky130_fd_sc_hd__decap_3
XFILLER_112_507 VGND VGND VPWR VPWR sky130_fd_sc_hd__decap_3
XFILLER_2_141 VGND VGND VPWR VPWR sky130_fd_sc_hd__fill_1
XFILLER_105_570 VGND VGND VPWR VPWR sky130_fd_sc_hd__decap_3
XPHY_EDGE_ROW_70_Right_70 VGND VGND VPWR VPWR sky130_fd_sc_hd__decap_3
XFILLER_78_421 VGND VGND VPWR VPWR sky130_fd_sc_hd__decap_3
XFILLER_3_697 VGND VGND VPWR VPWR sky130_fd_sc_hd__decap_3
XFILLER_120_551 VGND VGND VPWR VPWR sky130_fd_sc_hd__decap_3
XFILLER_38_307 VGND VGND VPWR VPWR sky130_fd_sc_hd__fill_1
XFILLER_66_627 VGND VGND VPWR VPWR sky130_fd_sc_hd__decap_3
Xsingle_cycle_cpu_577 VGND VGND VPWR VPWR single_cycle_cpu_577/HI instruction_out[29]
+ sky130_fd_sc_hd__conb_1
XFILLER_78_498 VGND VGND VPWR VPWR sky130_fd_sc_hd__decap_3
XFILLER_120_584 VGND VGND VPWR VPWR sky130_fd_sc_hd__decap_3
XFILLER_65_126 VGND VGND VPWR VPWR sky130_fd_sc_hd__decap_3
XFILLER_120_595 VGND VGND VPWR VPWR sky130_fd_sc_hd__decap_3
XFILLER_0_11 VGND VGND VPWR VPWR sky130_fd_sc_hd__decap_3
XFILLER_93_479 VGND VGND VPWR VPWR sky130_fd_sc_hd__decap_3
XFILLER_74_660 VGND VGND VPWR VPWR sky130_fd_sc_hd__decap_3
XFILLER_19_576 VGND VGND VPWR VPWR sky130_fd_sc_hd__decap_3
XTAP_TAPCELL_ROW_105_1628 VGND VPWR sky130_fd_sc_hd__tapvpwrvgnd_1
XFILLER_74_693 VGND VGND VPWR VPWR sky130_fd_sc_hd__decap_3
XFILLER_46_395 VGND VGND VPWR VPWR sky130_fd_sc_hd__decap_3
XFILLER_34_546 VGND VGND VPWR VPWR sky130_fd_sc_hd__decap_3
XFILLER_61_343 VGND VGND VPWR VPWR sky130_fd_sc_hd__decap_3
XFILLER_64_91 VGND VGND VPWR VPWR sky130_fd_sc_hd__fill_1
XFILLER_22_719 VGND VGND VPWR VPWR sky130_fd_sc_hd__decap_3
X_4730_ _7007_/Q _4738_/A VGND VGND VPWR VPWR _4731_/A sky130_fd_sc_hd__or2_2
XTAP_TAPCELL_ROW_64_1093 VGND VPWR sky130_fd_sc_hd__tapvpwrvgnd_1
X_6400_ _6632_/A VGND VGND VPWR VPWR _6400_/Y sky130_fd_sc_hd__inv_2
X_3612_ _3536_/B _4614_/B _3610_/Y _3611_/Y VGND VGND VPWR VPWR _3612_/X sky130_fd_sc_hd__a211o_2
X_7380_ _7380_/CLK _7380_/D _6660_/Y VGND VGND VPWR VPWR _7380_/Q sky130_fd_sc_hd__dfrtp_2
XTAP_TAPCELL_ROW_40_791 VGND VPWR sky130_fd_sc_hd__tapvpwrvgnd_1
X_6331_ _6654_/A VGND VGND VPWR VPWR _6331_/Y sky130_fd_sc_hd__inv_2
Xhold904 _7057_/Q VGND VGND VPWR VPWR _7057_/D sky130_fd_sc_hd__dlygate4sd3_1
X_3543_ _3540_/X _3541_/X _5144_/A VGND VGND VPWR VPWR _3630_/B sky130_fd_sc_hd__o21ai_2
Xhold915 _6715_/Q VGND VGND VPWR VPWR hold915/X sky130_fd_sc_hd__dlygate4sd3_1
Xhold926 _6717_/Q VGND VGND VPWR VPWR hold926/X sky130_fd_sc_hd__dlygate4sd3_1
XFILLER_115_323 VGND VGND VPWR VPWR sky130_fd_sc_hd__decap_3
Xhold937 _7189_/Q VGND VGND VPWR VPWR hold937/X sky130_fd_sc_hd__dlygate4sd3_1
Xhold948 _7387_/Q VGND VGND VPWR VPWR hold948/X sky130_fd_sc_hd__dlygate4sd3_1
XTAP_TAPCELL_ROW_116_1779 VGND VPWR sky130_fd_sc_hd__tapvpwrvgnd_1
X_6262_ _6660_/A VGND VGND VPWR VPWR _6262_/Y sky130_fd_sc_hd__inv_2
Xhold959 _7389_/Q VGND VGND VPWR VPWR hold959/X sky130_fd_sc_hd__dlygate4sd3_1
X_3474_ _7280_/Q _4534_/S _3366_/X _7152_/Q _3473_/X VGND VGND VPWR VPWR _3474_/X
+ sky130_fd_sc_hd__a221o_2
XFILLER_115_356 VGND VGND VPWR VPWR sky130_fd_sc_hd__decap_3
X_5213_ _5213_/A _5223_/B VGND VGND VPWR VPWR _7222_/D sky130_fd_sc_hd__and2_2
XFILLER_88_229 VGND VGND VPWR VPWR sky130_fd_sc_hd__decap_3
X_5144_ _5144_/A _5144_/B VGND VGND VPWR VPWR _5145_/A sky130_fd_sc_hd__nand2_2
XFILLER_111_540 VGND VGND VPWR VPWR sky130_fd_sc_hd__decap_3
XFILLER_57_605 VGND VGND VPWR VPWR sky130_fd_sc_hd__decap_3
XFILLER_69_476 VGND VGND VPWR VPWR sky130_fd_sc_hd__fill_1
XFILLER_29_307 VGND VGND VPWR VPWR sky130_fd_sc_hd__decap_3
XFILLER_28_29 VGND VGND VPWR VPWR sky130_fd_sc_hd__decap_3
XFILLER_111_573 VGND VGND VPWR VPWR sky130_fd_sc_hd__decap_3
XFILLER_69_498 VGND VGND VPWR VPWR sky130_fd_sc_hd__decap_3
XFILLER_57_638 VGND VGND VPWR VPWR sky130_fd_sc_hd__decap_3
X_5075_ _5075_/A _5075_/B _5075_/C VGND VGND VPWR VPWR _5658_/A sky130_fd_sc_hd__or3_2
XFILLER_72_619 VGND VGND VPWR VPWR sky130_fd_sc_hd__decap_3
XFILLER_37_340 VGND VGND VPWR VPWR sky130_fd_sc_hd__decap_3
XFILLER_65_671 VGND VGND VPWR VPWR sky130_fd_sc_hd__fill_1
XFILLER_25_502 VGND VGND VPWR VPWR sky130_fd_sc_hd__fill_2
XFILLER_65_682 VGND VGND VPWR VPWR sky130_fd_sc_hd__decap_3
XTAP_TAPCELL_ROW_48_891 VGND VPWR sky130_fd_sc_hd__tapvpwrvgnd_1
XFILLER_52_332 VGND VGND VPWR VPWR sky130_fd_sc_hd__decap_3
XFILLER_52_343 VGND VGND VPWR VPWR sky130_fd_sc_hd__decap_3
XFILLER_80_663 VGND VGND VPWR VPWR sky130_fd_sc_hd__decap_3
XFILLER_52_365 VGND VGND VPWR VPWR sky130_fd_sc_hd__decap_3
XFILLER_25_579 VGND VGND VPWR VPWR sky130_fd_sc_hd__decap_3
XFILLER_40_516 VGND VGND VPWR VPWR sky130_fd_sc_hd__decap_3
XFILLER_80_696 VGND VGND VPWR VPWR sky130_fd_sc_hd__decap_3
X_4928_ _6996_/Q _4928_/B _4943_/A VGND VGND VPWR VPWR _4928_/Y sky130_fd_sc_hd__nor3_2
XFILLER_33_590 VGND VGND VPWR VPWR sky130_fd_sc_hd__decap_3
XFILLER_100_56 VGND VGND VPWR VPWR sky130_fd_sc_hd__decap_3
X_4859_ _7000_/Q _4870_/A VGND VGND VPWR VPWR _4859_/Y sky130_fd_sc_hd__nor2_2
XFILLER_20_262 VGND VGND VPWR VPWR sky130_fd_sc_hd__decap_3
XFILLER_119_662 VGND VGND VPWR VPWR sky130_fd_sc_hd__decap_3
Xclkbuf_3_0__f_clk clkbuf_0_clk/X VGND VGND VPWR VPWR clkbuf_leaf_1_clk/A sky130_fd_sc_hd__clkbuf_16
XFILLER_109_21 VGND VGND VPWR VPWR sky130_fd_sc_hd__decap_3
XFILLER_119_673 VGND VGND VPWR VPWR sky130_fd_sc_hd__decap_3
XFILLER_114_6 VGND VGND VPWR VPWR sky130_fd_sc_hd__decap_3
XFILLER_106_301 VGND VGND VPWR VPWR sky130_fd_sc_hd__decap_3
X_6529_ _6594_/A VGND VGND VPWR VPWR _6529_/Y sky130_fd_sc_hd__inv_2
XFILLER_106_312 VGND VGND VPWR VPWR sky130_fd_sc_hd__decap_3
XFILLER_109_54 VGND VGND VPWR VPWR sky130_fd_sc_hd__fill_2
XFILLER_118_194 VGND VGND VPWR VPWR sky130_fd_sc_hd__fill_2
XFILLER_106_334 VGND VGND VPWR VPWR sky130_fd_sc_hd__decap_3
XFILLER_69_36 VGND VGND VPWR VPWR sky130_fd_sc_hd__decap_3
XFILLER_121_326 VGND VGND VPWR VPWR sky130_fd_sc_hd__decap_3
XFILLER_121_337 VGND VGND VPWR VPWR sky130_fd_sc_hd__decap_3
XFILLER_0_656 VGND VGND VPWR VPWR sky130_fd_sc_hd__decap_3
XFILLER_87_251 VGND VGND VPWR VPWR sky130_fd_sc_hd__decap_3
XFILLER_102_551 VGND VGND VPWR VPWR sky130_fd_sc_hd__decap_3
XFILLER_75_402 VGND VGND VPWR VPWR sky130_fd_sc_hd__decap_3
XFILLER_48_627 VGND VGND VPWR VPWR sky130_fd_sc_hd__decap_3
XFILLER_102_584 VGND VGND VPWR VPWR sky130_fd_sc_hd__decap_3
XFILLER_102_595 VGND VGND VPWR VPWR sky130_fd_sc_hd__decap_3
XFILLER_85_57 VGND VGND VPWR VPWR sky130_fd_sc_hd__decap_3
XFILLER_75_446 VGND VGND VPWR VPWR sky130_fd_sc_hd__fill_2
XFILLER_85_79 VGND VGND VPWR VPWR sky130_fd_sc_hd__decap_3
XFILLER_56_660 VGND VGND VPWR VPWR sky130_fd_sc_hd__decap_3
XFILLER_28_351 VGND VGND VPWR VPWR sky130_fd_sc_hd__decap_3
XFILLER_56_693 VGND VGND VPWR VPWR sky130_fd_sc_hd__decap_3
XFILLER_90_449 VGND VGND VPWR VPWR sky130_fd_sc_hd__decap_3
XFILLER_71_641 VGND VGND VPWR VPWR sky130_fd_sc_hd__decap_3
XFILLER_43_343 VGND VGND VPWR VPWR sky130_fd_sc_hd__decap_3
XFILLER_31_505 VGND VGND VPWR VPWR sky130_fd_sc_hd__decap_3
XFILLER_16_579 VGND VGND VPWR VPWR sky130_fd_sc_hd__decap_3
XFILLER_71_685 VGND VGND VPWR VPWR sky130_fd_sc_hd__decap_3
XFILLER_70_162 VGND VGND VPWR VPWR sky130_fd_sc_hd__decap_3
XFILLER_8_701 VGND VGND VPWR VPWR sky130_fd_sc_hd__decap_3
XTAP_TAPCELL_ROW_100_1569 VGND VPWR sky130_fd_sc_hd__tapvpwrvgnd_1
XFILLER_8_734 VGND VGND VPWR VPWR sky130_fd_sc_hd__fill_1
XFILLER_79_9 VGND VGND VPWR VPWR sky130_fd_sc_hd__fill_1
XFILLER_11_284 VGND VGND VPWR VPWR sky130_fd_sc_hd__fill_1
XFILLER_7_244 VGND VGND VPWR VPWR sky130_fd_sc_hd__fill_1
XFILLER_11_295 VGND VGND VPWR VPWR sky130_fd_sc_hd__decap_3
XFILLER_7_266 VGND VGND VPWR VPWR sky130_fd_sc_hd__decap_3
XFILLER_50_71 VGND VGND VPWR VPWR sky130_fd_sc_hd__decap_3
XFILLER_3_461 VGND VGND VPWR VPWR sky130_fd_sc_hd__decap_3
XFILLER_112_315 VGND VGND VPWR VPWR sky130_fd_sc_hd__decap_3
XFILLER_112_359 VGND VGND VPWR VPWR sky130_fd_sc_hd__decap_3
XFILLER_59_91 VGND VGND VPWR VPWR sky130_fd_sc_hd__decap_3
XFILLER_39_605 VGND VGND VPWR VPWR sky130_fd_sc_hd__decap_3
XFILLER_78_251 VGND VGND VPWR VPWR sky130_fd_sc_hd__fill_1
XFILLER_66_402 VGND VGND VPWR VPWR sky130_fd_sc_hd__decap_3
XFILLER_94_722 VGND VGND VPWR VPWR sky130_fd_sc_hd__decap_3
XFILLER_66_413 VGND VGND VPWR VPWR sky130_fd_sc_hd__decap_3
XFILLER_78_284 VGND VGND VPWR VPWR sky130_fd_sc_hd__fill_2
XFILLER_39_638 VGND VGND VPWR VPWR sky130_fd_sc_hd__decap_3
XFILLER_93_221 VGND VGND VPWR VPWR sky130_fd_sc_hd__decap_3
XFILLER_120_392 VGND VGND VPWR VPWR sky130_fd_sc_hd__decap_3
XFILLER_93_243 VGND VGND VPWR VPWR sky130_fd_sc_hd__decap_3
XFILLER_54_619 VGND VGND VPWR VPWR sky130_fd_sc_hd__decap_3
XFILLER_93_276 VGND VGND VPWR VPWR sky130_fd_sc_hd__decap_3
XFILLER_47_671 VGND VGND VPWR VPWR sky130_fd_sc_hd__fill_1
XFILLER_93_287 VGND VGND VPWR VPWR sky130_fd_sc_hd__decap_3
XFILLER_47_682 VGND VGND VPWR VPWR sky130_fd_sc_hd__decap_3
XTAP_TAPCELL_ROW_66_1122 VGND VPWR sky130_fd_sc_hd__tapvpwrvgnd_1
X_6880_ _6926_/CLK _6880_/D VGND VGND VPWR VPWR _6880_/Q sky130_fd_sc_hd__dfxtp_2
XFILLER_74_490 VGND VGND VPWR VPWR sky130_fd_sc_hd__decap_3
XFILLER_62_641 VGND VGND VPWR VPWR sky130_fd_sc_hd__decap_3
XFILLER_34_343 VGND VGND VPWR VPWR sky130_fd_sc_hd__decap_3
XTAP_TAPCELL_ROW_45_850 VGND VPWR sky130_fd_sc_hd__tapvpwrvgnd_1
XFILLER_62_663 VGND VGND VPWR VPWR sky130_fd_sc_hd__decap_3
XFILLER_34_365 VGND VGND VPWR VPWR sky130_fd_sc_hd__decap_3
XFILLER_62_696 VGND VGND VPWR VPWR sky130_fd_sc_hd__decap_3
XFILLER_61_184 VGND VGND VPWR VPWR sky130_fd_sc_hd__fill_1
X_4713_ _7008_/Q _4731_/B VGND VGND VPWR VPWR _7008_/D sky130_fd_sc_hd__xnor2_2
X_5693_ _7352_/Q _5693_/A1 _5708_/S VGND VGND VPWR VPWR _6696_/D sky130_fd_sc_hd__mux2_2
X_4644_ _4111_/B _4643_/Y _4633_/A _4109_/X VGND VGND VPWR VPWR _4644_/X sky130_fd_sc_hd__a211o_2
XFILLER_116_610 VGND VGND VPWR VPWR sky130_fd_sc_hd__decap_3
X_4575_ _4575_/A _4577_/B VGND VGND VPWR VPWR _7293_/D sky130_fd_sc_hd__and2_2
Xhold701 _6877_/Q VGND VGND VPWR VPWR _6877_/D sky130_fd_sc_hd__dlygate4sd3_1
X_7363_ _7365_/CLK _7363_/D _6643_/Y VGND VGND VPWR VPWR _7363_/Q sky130_fd_sc_hd__dfrtp_2
Xhold712 _6953_/Q VGND VGND VPWR VPWR _6953_/D sky130_fd_sc_hd__dlygate4sd3_1
Xhold723 _6916_/Q VGND VGND VPWR VPWR _6916_/D sky130_fd_sc_hd__dlygate4sd3_1
XFILLER_116_643 VGND VGND VPWR VPWR sky130_fd_sc_hd__fill_1
XTAP_TAPCELL_ROW_77_1262 VGND VPWR sky130_fd_sc_hd__tapvpwrvgnd_1
X_3526_ _4938_/A _5114_/A VGND VGND VPWR VPWR _5057_/A sky130_fd_sc_hd__nand2_2
X_6314_ _6632_/A VGND VGND VPWR VPWR _6314_/Y sky130_fd_sc_hd__inv_2
Xhold734 _6899_/Q VGND VGND VPWR VPWR _6899_/D sky130_fd_sc_hd__dlygate4sd3_1
XFILLER_116_654 VGND VGND VPWR VPWR sky130_fd_sc_hd__decap_3
XTAP_TAPCELL_ROW_77_1273 VGND VPWR sky130_fd_sc_hd__tapvpwrvgnd_1
Xhold745 _6827_/Q VGND VGND VPWR VPWR _6827_/D sky130_fd_sc_hd__dlygate4sd3_1
X_7294_ _7359_/CLK _7294_/D _6574_/Y VGND VGND VPWR VPWR _7294_/Q sky130_fd_sc_hd__dfrtp_2
XFILLER_89_505 VGND VGND VPWR VPWR sky130_fd_sc_hd__decap_3
Xhold756 _6747_/Q VGND VGND VPWR VPWR _6747_/D sky130_fd_sc_hd__dlygate4sd3_1
Xhold767 _6776_/Q VGND VGND VPWR VPWR _6776_/D sky130_fd_sc_hd__dlygate4sd3_1
XFILLER_116_687 VGND VGND VPWR VPWR sky130_fd_sc_hd__decap_3
Xhold778 _6825_/Q VGND VGND VPWR VPWR _6825_/D sky130_fd_sc_hd__dlygate4sd3_1
XFILLER_115_175 VGND VGND VPWR VPWR sky130_fd_sc_hd__fill_2
X_3457_ _4394_/A _3449_/C _4327_/A _3456_/X VGND VGND VPWR VPWR _3506_/B sky130_fd_sc_hd__a22o_2
Xhold789 _6902_/Q VGND VGND VPWR VPWR _6902_/D sky130_fd_sc_hd__dlygate4sd3_1
XFILLER_115_186 VGND VGND VPWR VPWR sky130_fd_sc_hd__decap_3
XFILLER_103_337 VGND VGND VPWR VPWR sky130_fd_sc_hd__decap_3
XTAP_TAPCELL_ROW_90_1440 VGND VPWR sky130_fd_sc_hd__tapvpwrvgnd_1
XFILLER_69_240 VGND VGND VPWR VPWR sky130_fd_sc_hd__decap_3
X_3388_ _3394_/A _3429_/B VGND VGND VPWR VPWR _3556_/A sky130_fd_sc_hd__nor2_2
XFILLER_85_700 VGND VGND VPWR VPWR sky130_fd_sc_hd__decap_3
XFILLER_57_402 VGND VGND VPWR VPWR sky130_fd_sc_hd__fill_2
XFILLER_97_582 VGND VGND VPWR VPWR sky130_fd_sc_hd__decap_3
XFILLER_69_284 VGND VGND VPWR VPWR sky130_fd_sc_hd__decap_3
XFILLER_29_126 VGND VGND VPWR VPWR sky130_fd_sc_hd__fill_2
XFILLER_84_232 VGND VGND VPWR VPWR sky130_fd_sc_hd__decap_3
XPHY_EDGE_ROW_2_Right_2 VGND VGND VPWR VPWR sky130_fd_sc_hd__decap_3
XFILLER_29_148 VGND VGND VPWR VPWR sky130_fd_sc_hd__fill_1
X_5058_ _5072_/A _4330_/B _5056_/X _5057_/Y VGND VGND VPWR VPWR _5662_/B sky130_fd_sc_hd__a211o_2
XFILLER_55_27 VGND VGND VPWR VPWR sky130_fd_sc_hd__fill_2
XFILLER_38_660 VGND VGND VPWR VPWR sky130_fd_sc_hd__decap_3
XFILLER_72_416 VGND VGND VPWR VPWR sky130_fd_sc_hd__decap_3
XFILLER_55_38 VGND VGND VPWR VPWR sky130_fd_sc_hd__fill_1
XFILLER_84_287 VGND VGND VPWR VPWR sky130_fd_sc_hd__decap_3
XFILLER_72_427 VGND VGND VPWR VPWR sky130_fd_sc_hd__fill_2
XFILLER_38_693 VGND VGND VPWR VPWR sky130_fd_sc_hd__decap_3
XFILLER_53_641 VGND VGND VPWR VPWR sky130_fd_sc_hd__decap_3
XFILLER_111_33 VGND VGND VPWR VPWR sky130_fd_sc_hd__decap_3
XFILLER_25_365 VGND VGND VPWR VPWR sky130_fd_sc_hd__decap_3
XFILLER_53_685 VGND VGND VPWR VPWR sky130_fd_sc_hd__decap_3
XFILLER_71_15 VGND VGND VPWR VPWR sky130_fd_sc_hd__decap_3
XFILLER_111_66 VGND VGND VPWR VPWR sky130_fd_sc_hd__decap_3
XFILLER_52_173 VGND VGND VPWR VPWR sky130_fd_sc_hd__fill_2
XFILLER_40_357 VGND VGND VPWR VPWR sky130_fd_sc_hd__decap_3
XFILLER_40_368 VGND VGND VPWR VPWR sky130_fd_sc_hd__decap_3
XTAP_TAPCELL_ROW_23_566 VGND VPWR sky130_fd_sc_hd__tapvpwrvgnd_1
XFILLER_21_571 VGND VGND VPWR VPWR sky130_fd_sc_hd__decap_3
XFILLER_5_715 VGND VGND VPWR VPWR sky130_fd_sc_hd__decap_3
XFILLER_4_203 VGND VGND VPWR VPWR sky130_fd_sc_hd__decap_3
XFILLER_119_481 VGND VGND VPWR VPWR sky130_fd_sc_hd__decap_3
XFILLER_107_632 VGND VGND VPWR VPWR sky130_fd_sc_hd__decap_3
XFILLER_4_236 VGND VGND VPWR VPWR sky130_fd_sc_hd__decap_3
XFILLER_106_131 VGND VGND VPWR VPWR sky130_fd_sc_hd__decap_3
XFILLER_107_665 VGND VGND VPWR VPWR sky130_fd_sc_hd__decap_3
XFILLER_107_676 VGND VGND VPWR VPWR sky130_fd_sc_hd__decap_3
XFILLER_122_613 VGND VGND VPWR VPWR sky130_fd_sc_hd__decap_3
XFILLER_106_164 VGND VGND VPWR VPWR sky130_fd_sc_hd__decap_3
XFILLER_106_175 VGND VGND VPWR VPWR sky130_fd_sc_hd__decap_3
XFILLER_106_197 VGND VGND VPWR VPWR sky130_fd_sc_hd__decap_3
XFILLER_122_657 VGND VGND VPWR VPWR sky130_fd_sc_hd__decap_3
XFILLER_121_134 VGND VGND VPWR VPWR sky130_fd_sc_hd__decap_3
XFILLER_88_571 VGND VGND VPWR VPWR sky130_fd_sc_hd__decap_3
XFILLER_76_722 VGND VGND VPWR VPWR sky130_fd_sc_hd__decap_3
XFILLER_0_497 VGND VGND VPWR VPWR sky130_fd_sc_hd__decap_3
XFILLER_48_446 VGND VGND VPWR VPWR sky130_fd_sc_hd__decap_3
XFILLER_102_392 VGND VGND VPWR VPWR sky130_fd_sc_hd__decap_3
XFILLER_91_703 VGND VGND VPWR VPWR sky130_fd_sc_hd__decap_3
XFILLER_36_619 VGND VGND VPWR VPWR sky130_fd_sc_hd__decap_3
XFILLER_63_416 VGND VGND VPWR VPWR sky130_fd_sc_hd__decap_3
XFILLER_75_287 VGND VGND VPWR VPWR sky130_fd_sc_hd__decap_3
XFILLER_29_671 VGND VGND VPWR VPWR sky130_fd_sc_hd__fill_1
XFILLER_29_682 VGND VGND VPWR VPWR sky130_fd_sc_hd__decap_3
Xplace405 _4534_/S VGND VGND VPWR VPWR _4244_/B sky130_fd_sc_hd__buf_2
XFILLER_75_298 VGND VGND VPWR VPWR sky130_fd_sc_hd__decap_3
XPHY_EDGE_ROW_11_Left_135 VGND VGND VPWR VPWR sky130_fd_sc_hd__decap_3
Xplace416 _4268_/B1 VGND VGND VPWR VPWR _4419_/B1 sky130_fd_sc_hd__buf_2
XFILLER_63_449 VGND VGND VPWR VPWR sky130_fd_sc_hd__decap_3
XFILLER_44_630 VGND VGND VPWR VPWR sky130_fd_sc_hd__decap_3
XFILLER_16_321 VGND VGND VPWR VPWR sky130_fd_sc_hd__decap_3
Xplace427 _3958_/S VGND VGND VPWR VPWR _3956_/S sky130_fd_sc_hd__buf_2
Xplace438 _3341_/A VGND VGND VPWR VPWR _5156_/S sky130_fd_sc_hd__buf_2
XFILLER_45_60 VGND VGND VPWR VPWR sky130_fd_sc_hd__fill_2
Xplace449 _7010_/Q VGND VGND VPWR VPWR _7010_/D sky130_fd_sc_hd__buf_2
XFILLER_44_663 VGND VGND VPWR VPWR sky130_fd_sc_hd__decap_3
XFILLER_43_151 VGND VGND VPWR VPWR sky130_fd_sc_hd__decap_3
XFILLER_16_376 VGND VGND VPWR VPWR sky130_fd_sc_hd__decap_3
XFILLER_71_482 VGND VGND VPWR VPWR sky130_fd_sc_hd__decap_3
XFILLER_44_696 VGND VGND VPWR VPWR sky130_fd_sc_hd__decap_3
XFILLER_31_335 VGND VGND VPWR VPWR sky130_fd_sc_hd__fill_1
XFILLER_31_346 VGND VGND VPWR VPWR sky130_fd_sc_hd__decap_3
XFILLER_31_368 VGND VGND VPWR VPWR sky130_fd_sc_hd__decap_3
XTAP_TAPCELL_ROW_61_1063 VGND VPWR sky130_fd_sc_hd__tapvpwrvgnd_1
XFILLER_12_571 VGND VGND VPWR VPWR sky130_fd_sc_hd__decap_3
XFILLER_8_531 VGND VGND VPWR VPWR sky130_fd_sc_hd__fill_1
XFILLER_8_542 VGND VGND VPWR VPWR sky130_fd_sc_hd__decap_3
XFILLER_77_6 VGND VGND VPWR VPWR sky130_fd_sc_hd__decap_3
XFILLER_8_575 VGND VGND VPWR VPWR sky130_fd_sc_hd__decap_3
XANTENNA_3 _3331_/A VGND VGND VPWR VPWR sky130_fd_sc_hd__diode_2
XPHY_EDGE_ROW_20_Left_144 VGND VGND VPWR VPWR sky130_fd_sc_hd__decap_3
X_4360_ _5072_/B _5071_/B VGND VGND VPWR VPWR _5073_/A sky130_fd_sc_hd__nand2_2
XTAP_TAPCELL_ROW_113_1738 VGND VPWR sky130_fd_sc_hd__tapvpwrvgnd_1
X_3311_ _5118_/C _4696_/B _3340_/B VGND VGND VPWR VPWR _5671_/A sky130_fd_sc_hd__o21ai_2
XFILLER_113_635 VGND VGND VPWR VPWR sky130_fd_sc_hd__decap_3
XFILLER_112_101 VGND VGND VPWR VPWR sky130_fd_sc_hd__decap_3
X_4291_ _4612_/A _4612_/B VGND VGND VPWR VPWR _4292_/C sky130_fd_sc_hd__xnor2_2
XFILLER_98_357 VGND VGND VPWR VPWR sky130_fd_sc_hd__decap_3
XFILLER_113_668 VGND VGND VPWR VPWR sky130_fd_sc_hd__decap_3
XFILLER_98_368 VGND VGND VPWR VPWR sky130_fd_sc_hd__fill_1
XFILLER_113_679 VGND VGND VPWR VPWR sky130_fd_sc_hd__decap_3
XFILLER_67_700 VGND VGND VPWR VPWR sky130_fd_sc_hd__decap_3
XFILLER_66_243 VGND VGND VPWR VPWR sky130_fd_sc_hd__fill_2
XFILLER_27_608 VGND VGND VPWR VPWR sky130_fd_sc_hd__decap_3
XFILLER_94_574 VGND VGND VPWR VPWR sky130_fd_sc_hd__decap_3
XFILLER_66_265 VGND VGND VPWR VPWR sky130_fd_sc_hd__decap_3
XFILLER_82_725 VGND VGND VPWR VPWR sky130_fd_sc_hd__decap_3
XFILLER_54_427 VGND VGND VPWR VPWR sky130_fd_sc_hd__decap_3
X_6932_ _7401_/CLK _6932_/D VGND VGND VPWR VPWR _6932_/Q sky130_fd_sc_hd__dfxtp_2
XFILLER_54_449 VGND VGND VPWR VPWR sky130_fd_sc_hd__decap_3
XFILLER_81_246 VGND VGND VPWR VPWR sky130_fd_sc_hd__decap_3
XFILLER_35_641 VGND VGND VPWR VPWR sky130_fd_sc_hd__decap_3
X_6863_ clkload8/A _6863_/D VGND VGND VPWR VPWR _6863_/Q sky130_fd_sc_hd__dfxtp_2
XFILLER_62_460 VGND VGND VPWR VPWR sky130_fd_sc_hd__decap_3
XFILLER_35_685 VGND VGND VPWR VPWR sky130_fd_sc_hd__decap_3
XFILLER_50_622 VGND VGND VPWR VPWR sky130_fd_sc_hd__decap_3
XFILLER_34_195 VGND VGND VPWR VPWR sky130_fd_sc_hd__fill_1
X_6794_ _7215_/CLK _6794_/D VGND VGND VPWR VPWR _6794_/Q sky130_fd_sc_hd__dfxtp_2
XFILLER_50_666 VGND VGND VPWR VPWR sky130_fd_sc_hd__decap_3
XFILLER_50_699 VGND VGND VPWR VPWR sky130_fd_sc_hd__fill_1
XTAP_TAPCELL_ROW_20_525 VGND VPWR sky130_fd_sc_hd__tapvpwrvgnd_1
X_5676_ _7344_/Q hold908/X _5708_/S VGND VGND VPWR VPWR _6688_/D sky130_fd_sc_hd__mux2_2
X_4627_ _4627_/A VGND VGND VPWR VPWR _4627_/Y sky130_fd_sc_hd__inv_2
X_7346_ _7355_/CLK _7346_/D _6626_/Y VGND VGND VPWR VPWR _7346_/Q sky130_fd_sc_hd__dfrtp_2
XFILLER_2_707 VGND VGND VPWR VPWR sky130_fd_sc_hd__decap_3
XFILLER_89_302 VGND VGND VPWR VPWR sky130_fd_sc_hd__decap_3
XFILLER_104_613 VGND VGND VPWR VPWR sky130_fd_sc_hd__decap_3
XFILLER_1_206 VGND VGND VPWR VPWR sky130_fd_sc_hd__decap_3
X_3509_ _5640_/B _3509_/B VGND VGND VPWR VPWR _3509_/Y sky130_fd_sc_hd__nor2_2
XFILLER_89_335 VGND VGND VPWR VPWR sky130_fd_sc_hd__fill_1
XFILLER_1_228 VGND VGND VPWR VPWR sky130_fd_sc_hd__decap_3
Xhold586 _6786_/Q VGND VGND VPWR VPWR _6786_/D sky130_fd_sc_hd__dlygate4sd3_1
X_7277_ _7406_/CLK _7277_/D _6557_/Y VGND VGND VPWR VPWR _7277_/Q sky130_fd_sc_hd__dfrtp_2
Xhold597 _6947_/Q VGND VGND VPWR VPWR _6947_/D sky130_fd_sc_hd__dlygate4sd3_1
XFILLER_104_657 VGND VGND VPWR VPWR sky130_fd_sc_hd__decap_3
XFILLER_89_357 VGND VGND VPWR VPWR sky130_fd_sc_hd__decap_3
XFILLER_77_508 VGND VGND VPWR VPWR sky130_fd_sc_hd__decap_3
XFILLER_89_379 VGND VGND VPWR VPWR sky130_fd_sc_hd__decap_3
XFILLER_103_156 VGND VGND VPWR VPWR sky130_fd_sc_hd__decap_3
XFILLER_103_178 VGND VGND VPWR VPWR sky130_fd_sc_hd__decap_3
XFILLER_66_15 VGND VGND VPWR VPWR sky130_fd_sc_hd__decap_3
XFILLER_58_722 VGND VGND VPWR VPWR sky130_fd_sc_hd__decap_3
XFILLER_112_690 VGND VGND VPWR VPWR sky130_fd_sc_hd__decap_3
Xhold1220 _7307_/Q VGND VGND VPWR VPWR _4546_/A sky130_fd_sc_hd__dlygate4sd3_1
XFILLER_57_221 VGND VGND VPWR VPWR sky130_fd_sc_hd__decap_3
XFILLER_106_99 VGND VGND VPWR VPWR sky130_fd_sc_hd__fill_2
XFILLER_73_703 VGND VGND VPWR VPWR sky130_fd_sc_hd__decap_3
XFILLER_45_405 VGND VGND VPWR VPWR sky130_fd_sc_hd__fill_2
XFILLER_18_619 VGND VGND VPWR VPWR sky130_fd_sc_hd__decap_3
XFILLER_85_585 VGND VGND VPWR VPWR sky130_fd_sc_hd__decap_3
XFILLER_17_107 VGND VGND VPWR VPWR sky130_fd_sc_hd__decap_3
XFILLER_45_427 VGND VGND VPWR VPWR sky130_fd_sc_hd__decap_3
XFILLER_122_32 VGND VGND VPWR VPWR sky130_fd_sc_hd__decap_3
XTAP_TAPCELL_ROW_28_625 VGND VPWR sky130_fd_sc_hd__tapvpwrvgnd_1
XTAP_TAPCELL_ROW_28_636 VGND VPWR sky130_fd_sc_hd__tapvpwrvgnd_1
XFILLER_72_224 VGND VGND VPWR VPWR sky130_fd_sc_hd__decap_3
XFILLER_45_449 VGND VGND VPWR VPWR sky130_fd_sc_hd__decap_3
Xclkbuf_leaf_37_clk clkload1/A VGND VGND VPWR VPWR _7345_/CLK sky130_fd_sc_hd__clkbuf_16
XFILLER_122_65 VGND VGND VPWR VPWR sky130_fd_sc_hd__decap_3
XFILLER_72_257 VGND VGND VPWR VPWR sky130_fd_sc_hd__decap_3
XTAP_TAPCELL_ROW_0_250 VGND VPWR sky130_fd_sc_hd__tapvpwrvgnd_1
XTAP_TAPCELL_ROW_0_261 VGND VPWR sky130_fd_sc_hd__tapvpwrvgnd_1
XTAP_TAPCELL_ROW_56_989 VGND VPWR sky130_fd_sc_hd__tapvpwrvgnd_1
XFILLER_26_663 VGND VGND VPWR VPWR sky130_fd_sc_hd__decap_3
XTAP_TAPCELL_ROW_0_272 VGND VPWR sky130_fd_sc_hd__tapvpwrvgnd_1
XFILLER_82_58 VGND VGND VPWR VPWR sky130_fd_sc_hd__decap_3
XFILLER_13_302 VGND VGND VPWR VPWR sky130_fd_sc_hd__decap_3
XFILLER_26_696 VGND VGND VPWR VPWR sky130_fd_sc_hd__decap_3
XFILLER_13_324 VGND VGND VPWR VPWR sky130_fd_sc_hd__decap_3
XFILLER_41_644 VGND VGND VPWR VPWR sky130_fd_sc_hd__decap_3
XFILLER_15_74 VGND VGND VPWR VPWR sky130_fd_sc_hd__decap_3
XFILLER_13_368 VGND VGND VPWR VPWR sky130_fd_sc_hd__decap_3
XFILLER_41_688 VGND VGND VPWR VPWR sky130_fd_sc_hd__decap_3
XFILLER_5_534 VGND VGND VPWR VPWR sky130_fd_sc_hd__decap_3
XFILLER_5_567 VGND VGND VPWR VPWR sky130_fd_sc_hd__decap_3
XFILLER_122_432 VGND VGND VPWR VPWR sky130_fd_sc_hd__decap_3
XFILLER_122_465 VGND VGND VPWR VPWR sky130_fd_sc_hd__decap_3
XTAP_TAPCELL_ROW_8_372 VGND VPWR sky130_fd_sc_hd__tapvpwrvgnd_1
XFILLER_49_700 VGND VGND VPWR VPWR sky130_fd_sc_hd__decap_3
XFILLER_110_616 VGND VGND VPWR VPWR sky130_fd_sc_hd__decap_3
XFILLER_95_316 VGND VGND VPWR VPWR sky130_fd_sc_hd__decap_3
XFILLER_122_498 VGND VGND VPWR VPWR sky130_fd_sc_hd__decap_3
XFILLER_48_232 VGND VGND VPWR VPWR sky130_fd_sc_hd__decap_3
XFILLER_64_725 VGND VGND VPWR VPWR sky130_fd_sc_hd__decap_3
XFILLER_48_287 VGND VGND VPWR VPWR sky130_fd_sc_hd__decap_3
XFILLER_36_427 VGND VGND VPWR VPWR sky130_fd_sc_hd__decap_3
XFILLER_56_81 VGND VGND VPWR VPWR sky130_fd_sc_hd__decap_3
Xclkbuf_leaf_28_clk clkbuf_3_6__f_clk/X VGND VGND VPWR VPWR _7392_/CLK sky130_fd_sc_hd__clkbuf_16
XFILLER_17_641 VGND VGND VPWR VPWR sky130_fd_sc_hd__decap_3
XFILLER_51_408 VGND VGND VPWR VPWR sky130_fd_sc_hd__decap_3
XFILLER_91_588 VGND VGND VPWR VPWR sky130_fd_sc_hd__decap_3
XFILLER_17_685 VGND VGND VPWR VPWR sky130_fd_sc_hd__decap_3
Xplace268 _3749_/Y VGND VGND VPWR VPWR place268/X sky130_fd_sc_hd__buf_2
XFILLER_32_622 VGND VGND VPWR VPWR sky130_fd_sc_hd__decap_3
XFILLER_16_173 VGND VGND VPWR VPWR sky130_fd_sc_hd__fill_2
Xplace279 _3883_/B1 VGND VGND VPWR VPWR _3912_/B1 sky130_fd_sc_hd__buf_2
XFILLER_44_493 VGND VGND VPWR VPWR sky130_fd_sc_hd__decap_3
XFILLER_16_184 VGND VGND VPWR VPWR sky130_fd_sc_hd__decap_3
X_3860_ _3860_/A0 _3859_/X _3860_/S VGND VGND VPWR VPWR _7386_/D sky130_fd_sc_hd__mux2_2
XFILLER_32_666 VGND VGND VPWR VPWR sky130_fd_sc_hd__decap_3
X_3791_ _3775_/X _3790_/X _5151_/A VGND VGND VPWR VPWR _4961_/A sky130_fd_sc_hd__o21a_2
XFILLER_32_699 VGND VGND VPWR VPWR sky130_fd_sc_hd__fill_1
XFILLER_31_176 VGND VGND VPWR VPWR sky130_fd_sc_hd__decap_3
XFILLER_75_3 VGND VGND VPWR VPWR sky130_fd_sc_hd__decap_3
XFILLER_118_716 VGND VGND VPWR VPWR sky130_fd_sc_hd__decap_3
XFILLER_8_361 VGND VGND VPWR VPWR sky130_fd_sc_hd__decap_3
X_4412_ _4788_/B _4412_/B VGND VGND VPWR VPWR _4413_/A sky130_fd_sc_hd__or2_2
X_7200_ _7362_/CLK _7200_/D _6480_/Y VGND VGND VPWR VPWR _7200_/Q sky130_fd_sc_hd__dfrtp_2
X_5392_ _5392_/A0 _4945_/X _5398_/S VGND VGND VPWR VPWR _7137_/D sky130_fd_sc_hd__mux2_2
XFILLER_99_600 VGND VGND VPWR VPWR sky130_fd_sc_hd__decap_3
XPHY_EDGE_ROW_99_Right_99 VGND VGND VPWR VPWR sky130_fd_sc_hd__decap_3
XTAP_TAPCELL_ROW_74_1232 VGND VPWR sky130_fd_sc_hd__tapvpwrvgnd_1
X_4343_ _4365_/C _4365_/A _4365_/B VGND VGND VPWR VPWR _4343_/X sky130_fd_sc_hd__and3b_2
X_7131_ _7355_/CLK _7131_/D _6411_/Y VGND VGND VPWR VPWR _7131_/Q sky130_fd_sc_hd__dfrtp_2
XFILLER_99_644 VGND VGND VPWR VPWR sky130_fd_sc_hd__decap_3
XFILLER_98_121 VGND VGND VPWR VPWR sky130_fd_sc_hd__decap_3
XFILLER_113_421 VGND VGND VPWR VPWR sky130_fd_sc_hd__decap_3
XFILLER_59_508 VGND VGND VPWR VPWR sky130_fd_sc_hd__decap_3
X_7062_ _7279_/CLK _7062_/D _6342_/Y VGND VGND VPWR VPWR _7062_/Q sky130_fd_sc_hd__dfrtp_2
XFILLER_98_154 VGND VGND VPWR VPWR sky130_fd_sc_hd__decap_3
XFILLER_99_688 VGND VGND VPWR VPWR sky130_fd_sc_hd__decap_3
X_4274_ _4376_/A _4376_/B _4376_/C _4273_/D VGND VGND VPWR VPWR _4274_/Y sky130_fd_sc_hd__o31ai_2
XFILLER_86_305 VGND VGND VPWR VPWR sky130_fd_sc_hd__decap_3
XFILLER_101_638 VGND VGND VPWR VPWR sky130_fd_sc_hd__decap_3
XFILLER_39_221 VGND VGND VPWR VPWR sky130_fd_sc_hd__decap_3
XFILLER_39_243 VGND VGND VPWR VPWR sky130_fd_sc_hd__decap_3
XFILLER_100_159 VGND VGND VPWR VPWR sky130_fd_sc_hd__decap_3
XFILLER_55_703 VGND VGND VPWR VPWR sky130_fd_sc_hd__decap_3
XFILLER_27_405 VGND VGND VPWR VPWR sky130_fd_sc_hd__decap_3
XFILLER_94_371 VGND VGND VPWR VPWR sky130_fd_sc_hd__fill_1
XFILLER_54_202 VGND VGND VPWR VPWR sky130_fd_sc_hd__decap_3
XFILLER_36_29 VGND VGND VPWR VPWR sky130_fd_sc_hd__fill_1
XFILLER_82_533 VGND VGND VPWR VPWR sky130_fd_sc_hd__decap_3
XFILLER_39_298 VGND VGND VPWR VPWR sky130_fd_sc_hd__decap_3
XFILLER_54_235 VGND VGND VPWR VPWR sky130_fd_sc_hd__decap_3
XFILLER_27_449 VGND VGND VPWR VPWR sky130_fd_sc_hd__decap_3
Xclkbuf_leaf_19_clk clkbuf_3_6__f_clk/X VGND VGND VPWR VPWR _7398_/CLK sky130_fd_sc_hd__clkbuf_16
XFILLER_54_246 VGND VGND VPWR VPWR sky130_fd_sc_hd__decap_3
XFILLER_82_577 VGND VGND VPWR VPWR sky130_fd_sc_hd__decap_3
XFILLER_42_408 VGND VGND VPWR VPWR sky130_fd_sc_hd__decap_3
X_6915_ _6926_/CLK _6915_/D VGND VGND VPWR VPWR _6915_/Q sky130_fd_sc_hd__dfxtp_2
XFILLER_70_728 VGND VGND VPWR VPWR sky130_fd_sc_hd__decap_3
XFILLER_35_460 VGND VGND VPWR VPWR sky130_fd_sc_hd__decap_3
XTAP_TAPCELL_ROW_85_1372 VGND VPWR sky130_fd_sc_hd__tapvpwrvgnd_1
XFILLER_35_482 VGND VGND VPWR VPWR sky130_fd_sc_hd__decap_3
XTAP_TAPCELL_ROW_53_959 VGND VPWR sky130_fd_sc_hd__tapvpwrvgnd_1
XFILLER_23_644 VGND VGND VPWR VPWR sky130_fd_sc_hd__decap_3
X_6846_ clkload5/A _6846_/D VGND VGND VPWR VPWR _6846_/Q sky130_fd_sc_hd__dfxtp_2
XFILLER_50_430 VGND VGND VPWR VPWR sky130_fd_sc_hd__decap_3
XFILLER_23_688 VGND VGND VPWR VPWR sky130_fd_sc_hd__decap_3
X_6777_ _6926_/CLK _6777_/D VGND VGND VPWR VPWR _6777_/Q sky130_fd_sc_hd__dfxtp_2
X_3989_ _7346_/Q _4530_/A0 _3989_/S VGND VGND VPWR VPWR _7346_/D sky130_fd_sc_hd__mux2_2
XTAP_TAPCELL_ROW_33_694 VGND VPWR sky130_fd_sc_hd__tapvpwrvgnd_1
XFILLER_6_309 VGND VGND VPWR VPWR sky130_fd_sc_hd__decap_3
XFILLER_109_727 VGND VGND VPWR VPWR sky130_fd_sc_hd__fill_1
XFILLER_108_226 VGND VGND VPWR VPWR sky130_fd_sc_hd__decap_3
X_5659_ _5659_/A _5659_/B VGND VGND VPWR VPWR _5660_/D sky130_fd_sc_hd__nor2_2
XFILLER_2_504 VGND VGND VPWR VPWR sky130_fd_sc_hd__decap_3
XFILLER_117_21 VGND VGND VPWR VPWR sky130_fd_sc_hd__decap_3
X_7329_ _7365_/CLK _7329_/D _6609_/Y VGND VGND VPWR VPWR _7329_/Q sky130_fd_sc_hd__dfrtp_2
XFILLER_104_421 VGND VGND VPWR VPWR sky130_fd_sc_hd__decap_3
XFILLER_2_548 VGND VGND VPWR VPWR sky130_fd_sc_hd__decap_3
XFILLER_117_54 VGND VGND VPWR VPWR sky130_fd_sc_hd__fill_2
XFILLER_104_454 VGND VGND VPWR VPWR sky130_fd_sc_hd__decap_3
XFILLER_77_305 VGND VGND VPWR VPWR sky130_fd_sc_hd__decap_3
XFILLER_117_87 VGND VGND VPWR VPWR sky130_fd_sc_hd__decap_3
XTAP_TAPCELL_ROW_5_331 VGND VPWR sky130_fd_sc_hd__tapvpwrvgnd_1
XFILLER_77_349 VGND VGND VPWR VPWR sky130_fd_sc_hd__fill_1
XFILLER_58_530 VGND VGND VPWR VPWR sky130_fd_sc_hd__fill_2
XFILLER_92_319 VGND VGND VPWR VPWR sky130_fd_sc_hd__decap_3
XFILLER_100_660 VGND VGND VPWR VPWR sky130_fd_sc_hd__decap_3
Xhold1050 _7276_/Q VGND VGND VPWR VPWR _4753_/A0 sky130_fd_sc_hd__dlygate4sd3_1
XFILLER_85_360 VGND VGND VPWR VPWR sky130_fd_sc_hd__decap_3
XFILLER_85_371 VGND VGND VPWR VPWR sky130_fd_sc_hd__decap_3
XFILLER_46_725 VGND VGND VPWR VPWR sky130_fd_sc_hd__decap_3
XFILLER_45_202 VGND VGND VPWR VPWR sky130_fd_sc_hd__decap_3
Xhold1061 _7342_/Q VGND VGND VPWR VPWR _4474_/A0 sky130_fd_sc_hd__dlygate4sd3_1
XFILLER_58_596 VGND VGND VPWR VPWR sky130_fd_sc_hd__decap_3
XFILLER_18_427 VGND VGND VPWR VPWR sky130_fd_sc_hd__decap_3
Xhold1072 _7314_/Q VGND VGND VPWR VPWR _4530_/A0 sky130_fd_sc_hd__dlygate4sd3_1
XFILLER_100_693 VGND VGND VPWR VPWR sky130_fd_sc_hd__decap_3
Xhold1083 _7310_/Q VGND VGND VPWR VPWR _4540_/A sky130_fd_sc_hd__dlygate4sd3_1
XFILLER_85_393 VGND VGND VPWR VPWR sky130_fd_sc_hd__fill_2
Xhold1094 _7318_/Q VGND VGND VPWR VPWR _4522_/A0 sky130_fd_sc_hd__dlygate4sd3_1
XFILLER_61_706 VGND VGND VPWR VPWR sky130_fd_sc_hd__decap_3
XFILLER_45_268 VGND VGND VPWR VPWR sky130_fd_sc_hd__decap_3
XFILLER_73_599 VGND VGND VPWR VPWR sky130_fd_sc_hd__decap_3
XFILLER_26_471 VGND VGND VPWR VPWR sky130_fd_sc_hd__decap_3
XFILLER_14_622 VGND VGND VPWR VPWR sky130_fd_sc_hd__decap_3
XFILLER_13_110 VGND VGND VPWR VPWR sky130_fd_sc_hd__fill_2
XFILLER_53_290 VGND VGND VPWR VPWR sky130_fd_sc_hd__decap_3
XFILLER_14_666 VGND VGND VPWR VPWR sky130_fd_sc_hd__decap_3
XFILLER_41_474 VGND VGND VPWR VPWR sky130_fd_sc_hd__decap_3
XFILLER_14_699 VGND VGND VPWR VPWR sky130_fd_sc_hd__fill_1
XFILLER_9_169 VGND VGND VPWR VPWR sky130_fd_sc_hd__fill_2
XFILLER_114_218 VGND VGND VPWR VPWR sky130_fd_sc_hd__decap_3
XFILLER_107_281 VGND VGND VPWR VPWR sky130_fd_sc_hd__decap_3
XFILLER_107_292 VGND VGND VPWR VPWR sky130_fd_sc_hd__decap_3
XFILLER_3_11 VGND VGND VPWR VPWR sky130_fd_sc_hd__decap_3
XFILLER_96_625 VGND VGND VPWR VPWR sky130_fd_sc_hd__decap_3
XFILLER_95_102 VGND VGND VPWR VPWR sky130_fd_sc_hd__decap_3
XFILLER_95_113 VGND VGND VPWR VPWR sky130_fd_sc_hd__decap_3
XFILLER_1_570 VGND VGND VPWR VPWR sky130_fd_sc_hd__decap_3
XFILLER_110_424 VGND VGND VPWR VPWR sky130_fd_sc_hd__fill_2
XFILLER_95_135 VGND VGND VPWR VPWR sky130_fd_sc_hd__decap_3
XFILLER_96_669 VGND VGND VPWR VPWR sky130_fd_sc_hd__decap_3
XFILLER_3_99 VGND VGND VPWR VPWR sky130_fd_sc_hd__decap_3
XFILLER_37_703 VGND VGND VPWR VPWR sky130_fd_sc_hd__decap_3
XFILLER_64_511 VGND VGND VPWR VPWR sky130_fd_sc_hd__decap_3
XFILLER_64_533 VGND VGND VPWR VPWR sky130_fd_sc_hd__fill_1
XFILLER_36_224 VGND VGND VPWR VPWR sky130_fd_sc_hd__decap_3
XFILLER_36_246 VGND VGND VPWR VPWR sky130_fd_sc_hd__decap_3
XFILLER_91_352 VGND VGND VPWR VPWR sky130_fd_sc_hd__fill_1
XFILLER_52_728 VGND VGND VPWR VPWR sky130_fd_sc_hd__decap_3
XFILLER_51_205 VGND VGND VPWR VPWR sky130_fd_sc_hd__decap_3
X_4961_ _4961_/A _5662_/C _4961_/C VGND VGND VPWR VPWR _4961_/X sky130_fd_sc_hd__or3_4
XFILLER_91_396 VGND VGND VPWR VPWR sky130_fd_sc_hd__fill_2
X_6700_ _6926_/CLK _6700_/D VGND VGND VPWR VPWR _6700_/Q sky130_fd_sc_hd__dfxtp_2
XTAP_TAPCELL_ROW_121_1837 VGND VPWR sky130_fd_sc_hd__tapvpwrvgnd_1
X_3912_ _6905_/Q _3926_/A2 _3912_/B1 _6897_/Q VGND VGND VPWR VPWR _3912_/X sky130_fd_sc_hd__a22o_2
XFILLER_44_290 VGND VGND VPWR VPWR sky130_fd_sc_hd__decap_3
X_4892_ _4884_/X _4886_/X _4887_/Y _4891_/X VGND VGND VPWR VPWR _5656_/B sky130_fd_sc_hd__a31o_2
XTAP_TAPCELL_ROW_50_918 VGND VPWR sky130_fd_sc_hd__tapvpwrvgnd_1
X_6631_ _6632_/A VGND VGND VPWR VPWR _6631_/Y sky130_fd_sc_hd__inv_2
XFILLER_32_474 VGND VGND VPWR VPWR sky130_fd_sc_hd__fill_2
X_3843_ _6699_/Q _5660_/B _3665_/X _6877_/Q _3842_/X VGND VGND VPWR VPWR _3843_/X
+ sky130_fd_sc_hd__a221o_2
XFILLER_20_625 VGND VGND VPWR VPWR sky130_fd_sc_hd__decap_3
X_3774_ _6757_/Q _3884_/B1 _3883_/B1 _6769_/Q _3773_/X VGND VGND VPWR VPWR _3774_/X
+ sky130_fd_sc_hd__a221o_2
X_6562_ _6570_/A VGND VGND VPWR VPWR _6562_/Y sky130_fd_sc_hd__inv_2
XFILLER_20_669 VGND VGND VPWR VPWR sky130_fd_sc_hd__decap_3
XTAP_TAPCELL_ROW_30_653 VGND VPWR sky130_fd_sc_hd__tapvpwrvgnd_1
XFILLER_118_513 VGND VGND VPWR VPWR sky130_fd_sc_hd__decap_3
X_6493_ _6619_/A VGND VGND VPWR VPWR _6493_/Y sky130_fd_sc_hd__inv_2
XFILLER_118_557 VGND VGND VPWR VPWR sky130_fd_sc_hd__decap_3
XFILLER_8_191 VGND VGND VPWR VPWR sky130_fd_sc_hd__fill_2
XFILLER_106_719 VGND VGND VPWR VPWR sky130_fd_sc_hd__decap_3
Xclkbuf_leaf_8_clk clkbuf_leaf_9_clk/A VGND VGND VPWR VPWR _7386_/CLK sky130_fd_sc_hd__clkbuf_16
X_5375_ _5375_/A0 _4806_/X _5383_/S VGND VGND VPWR VPWR _7145_/D sky130_fd_sc_hd__mux2_2
XFILLER_99_441 VGND VGND VPWR VPWR sky130_fd_sc_hd__decap_3
Xoutput466 _5662_/A VGND VGND VPWR VPWR alu_result_out[14] sky130_fd_sc_hd__clkdlybuf4s25_1
Xoutput477 _5657_/A VGND VGND VPWR VPWR alu_result_out[24] sky130_fd_sc_hd__clkdlybuf4s25_1
X_7114_ _7374_/CLK _7114_/D _6394_/Y VGND VGND VPWR VPWR _7114_/Q sky130_fd_sc_hd__dfrtp_2
XFILLER_87_603 VGND VGND VPWR VPWR sky130_fd_sc_hd__decap_3
XFILLER_113_240 VGND VGND VPWR VPWR sky130_fd_sc_hd__fill_1
X_4326_ _7013_/Q _4356_/A2 _4322_/X _4325_/X VGND VGND VPWR VPWR _4327_/B sky130_fd_sc_hd__a211o_2
Xoutput488 _3746_/C VGND VGND VPWR VPWR alu_result_out[5] sky130_fd_sc_hd__clkdlybuf4s25_1
Xoutput499 _3394_/A VGND VGND VPWR VPWR instruction_out[16] sky130_fd_sc_hd__clkdlybuf4s25_1
XFILLER_59_316 VGND VGND VPWR VPWR sky130_fd_sc_hd__decap_3
XFILLER_86_102 VGND VGND VPWR VPWR sky130_fd_sc_hd__decap_3
XFILLER_101_413 VGND VGND VPWR VPWR sky130_fd_sc_hd__decap_3
XFILLER_87_647 VGND VGND VPWR VPWR sky130_fd_sc_hd__decap_3
XFILLER_113_284 VGND VGND VPWR VPWR sky130_fd_sc_hd__decap_3
X_4257_ _4626_/B _4626_/C _4256_/C VGND VGND VPWR VPWR _4988_/B sky130_fd_sc_hd__a21oi_2
X_7045_ _7362_/CLK _7045_/D _6325_/Y VGND VGND VPWR VPWR _7045_/Q sky130_fd_sc_hd__dfrtp_2
XFILLER_86_135 VGND VGND VPWR VPWR sky130_fd_sc_hd__decap_3
XFILLER_59_349 VGND VGND VPWR VPWR sky130_fd_sc_hd__fill_2
XFILLER_101_446 VGND VGND VPWR VPWR sky130_fd_sc_hd__fill_2
XFILLER_86_157 VGND VGND VPWR VPWR sky130_fd_sc_hd__decap_3
XTAP_TAPCELL_ROW_87_1401 VGND VPWR sky130_fd_sc_hd__tapvpwrvgnd_1
X_4188_ _7359_/Q _4261_/A2 _4187_/X _4347_/C1 VGND VGND VPWR VPWR _4188_/X sky130_fd_sc_hd__a211o_2
XFILLER_28_725 VGND VGND VPWR VPWR sky130_fd_sc_hd__decap_3
XFILLER_55_511 VGND VGND VPWR VPWR sky130_fd_sc_hd__decap_3
XFILLER_95_691 VGND VGND VPWR VPWR sky130_fd_sc_hd__decap_3
XFILLER_67_382 VGND VGND VPWR VPWR sky130_fd_sc_hd__fill_1
XFILLER_43_706 VGND VGND VPWR VPWR sky130_fd_sc_hd__decap_3
XFILLER_27_257 VGND VGND VPWR VPWR sky130_fd_sc_hd__decap_3
XTAP_TAPCELL_ROW_38_764 VGND VPWR sky130_fd_sc_hd__tapvpwrvgnd_1
XFILLER_15_408 VGND VGND VPWR VPWR sky130_fd_sc_hd__decap_3
XFILLER_15_419 VGND VGND VPWR VPWR sky130_fd_sc_hd__decap_3
XFILLER_103_78 VGND VGND VPWR VPWR sky130_fd_sc_hd__decap_3
XFILLER_82_385 VGND VGND VPWR VPWR sky130_fd_sc_hd__decap_3
XFILLER_70_536 VGND VGND VPWR VPWR sky130_fd_sc_hd__decap_3
XFILLER_42_227 VGND VGND VPWR VPWR sky130_fd_sc_hd__decap_3
XFILLER_70_569 VGND VGND VPWR VPWR sky130_fd_sc_hd__decap_3
XFILLER_35_290 VGND VGND VPWR VPWR sky130_fd_sc_hd__decap_3
XFILLER_23_441 VGND VGND VPWR VPWR sky130_fd_sc_hd__decap_3
XFILLER_23_452 VGND VGND VPWR VPWR sky130_fd_sc_hd__decap_3
XFILLER_11_603 VGND VGND VPWR VPWR sky130_fd_sc_hd__decap_3
X_6829_ clkload5/A _6829_/D VGND VGND VPWR VPWR _6829_/Q sky130_fd_sc_hd__dfxtp_2
XFILLER_50_271 VGND VGND VPWR VPWR sky130_fd_sc_hd__decap_3
XFILLER_23_496 VGND VGND VPWR VPWR sky130_fd_sc_hd__decap_3
XFILLER_11_647 VGND VGND VPWR VPWR sky130_fd_sc_hd__decap_3
XFILLER_109_502 VGND VGND VPWR VPWR sky130_fd_sc_hd__fill_2
XFILLER_7_629 VGND VGND VPWR VPWR sky130_fd_sc_hd__decap_3
XFILLER_10_168 VGND VGND VPWR VPWR sky130_fd_sc_hd__decap_3
XTAP_TAPCELL_ROW_98_1541 VGND VPWR sky130_fd_sc_hd__tapvpwrvgnd_1
XFILLER_6_139 VGND VGND VPWR VPWR sky130_fd_sc_hd__fill_1
XFILLER_109_546 VGND VGND VPWR VPWR sky130_fd_sc_hd__decap_3
XFILLER_109_579 VGND VGND VPWR VPWR sky130_fd_sc_hd__decap_3
XFILLER_2_312 VGND VGND VPWR VPWR sky130_fd_sc_hd__decap_3
XFILLER_88_57 VGND VGND VPWR VPWR sky130_fd_sc_hd__decap_3
XFILLER_104_240 VGND VGND VPWR VPWR sky130_fd_sc_hd__decap_3
XFILLER_78_625 VGND VGND VPWR VPWR sky130_fd_sc_hd__decap_3
XFILLER_2_378 VGND VGND VPWR VPWR sky130_fd_sc_hd__fill_1
XFILLER_77_102 VGND VGND VPWR VPWR sky130_fd_sc_hd__decap_3
XFILLER_120_722 VGND VGND VPWR VPWR sky130_fd_sc_hd__decap_3
XFILLER_77_113 VGND VGND VPWR VPWR sky130_fd_sc_hd__decap_3
XFILLER_78_669 VGND VGND VPWR VPWR sky130_fd_sc_hd__decap_3
XFILLER_93_606 VGND VGND VPWR VPWR sky130_fd_sc_hd__decap_3
XFILLER_93_617 VGND VGND VPWR VPWR sky130_fd_sc_hd__decap_3
XFILLER_65_308 VGND VGND VPWR VPWR sky130_fd_sc_hd__decap_3
XFILLER_19_703 VGND VGND VPWR VPWR sky130_fd_sc_hd__decap_3
XFILLER_92_127 VGND VGND VPWR VPWR sky130_fd_sc_hd__decap_3
XFILLER_46_533 VGND VGND VPWR VPWR sky130_fd_sc_hd__decap_3
XFILLER_92_149 VGND VGND VPWR VPWR sky130_fd_sc_hd__fill_2
XFILLER_73_330 VGND VGND VPWR VPWR sky130_fd_sc_hd__decap_3
XFILLER_18_235 VGND VGND VPWR VPWR sky130_fd_sc_hd__decap_3
XFILLER_73_352 VGND VGND VPWR VPWR sky130_fd_sc_hd__fill_2
XFILLER_34_728 VGND VGND VPWR VPWR sky130_fd_sc_hd__decap_3
XFILLER_61_514 VGND VGND VPWR VPWR sky130_fd_sc_hd__decap_3
XFILLER_46_599 VGND VGND VPWR VPWR sky130_fd_sc_hd__decap_3
XFILLER_73_396 VGND VGND VPWR VPWR sky130_fd_sc_hd__fill_1
XFILLER_61_558 VGND VGND VPWR VPWR sky130_fd_sc_hd__fill_2
XTAP_TAPCELL_ROW_16_469 VGND VPWR sky130_fd_sc_hd__tapvpwrvgnd_1
XFILLER_41_260 VGND VGND VPWR VPWR sky130_fd_sc_hd__decap_3
XFILLER_6_640 VGND VGND VPWR VPWR sky130_fd_sc_hd__decap_3
XFILLER_6_651 VGND VGND VPWR VPWR sky130_fd_sc_hd__decap_3
XTAP_TAPCELL_ROW_58_1024 VGND VPWR sky130_fd_sc_hd__tapvpwrvgnd_1
XFILLER_115_505 VGND VGND VPWR VPWR sky130_fd_sc_hd__decap_3
X_3490_ _7119_/Q _5229_/C _3489_/X _3556_/A VGND VGND VPWR VPWR _3490_/X sky130_fd_sc_hd__a211o_2
XFILLER_6_684 VGND VGND VPWR VPWR sky130_fd_sc_hd__decap_3
XFILLER_5_161 VGND VGND VPWR VPWR sky130_fd_sc_hd__decap_3
XFILLER_115_538 VGND VGND VPWR VPWR sky130_fd_sc_hd__decap_3
XFILLER_69_603 VGND VGND VPWR VPWR sky130_fd_sc_hd__decap_3
XFILLER_111_700 VGND VGND VPWR VPWR sky130_fd_sc_hd__decap_3
X_4111_ _4109_/X _4111_/B VGND VGND VPWR VPWR _4845_/A sky130_fd_sc_hd__nand2b_2
XFILLER_69_647 VGND VGND VPWR VPWR sky130_fd_sc_hd__decap_3
XFILLER_68_124 VGND VGND VPWR VPWR sky130_fd_sc_hd__decap_3
X_5091_ _6985_/Q _5068_/C _6986_/Q VGND VGND VPWR VPWR _5092_/B sky130_fd_sc_hd__a21o_2
XFILLER_96_444 VGND VGND VPWR VPWR sky130_fd_sc_hd__decap_3
XFILLER_68_135 VGND VGND VPWR VPWR sky130_fd_sc_hd__decap_3
XFILLER_96_477 VGND VGND VPWR VPWR sky130_fd_sc_hd__decap_3
X_4042_ _7341_/Q _3935_/S _4437_/B1 _7373_/Q _4429_/C1 VGND VGND VPWR VPWR _4042_/X
+ sky130_fd_sc_hd__a221o_2
XFILLER_84_628 VGND VGND VPWR VPWR sky130_fd_sc_hd__decap_3
XPHY_EDGE_ROW_3_Left_127 VGND VGND VPWR VPWR sky130_fd_sc_hd__decap_3
XFILLER_83_116 VGND VGND VPWR VPWR sky130_fd_sc_hd__decap_3
XFILLER_37_522 VGND VGND VPWR VPWR sky130_fd_sc_hd__decap_3
XFILLER_77_691 VGND VGND VPWR VPWR sky130_fd_sc_hd__decap_3
XFILLER_25_706 VGND VGND VPWR VPWR sky130_fd_sc_hd__decap_3
XTAP_TAPCELL_ROW_69_1164 VGND VPWR sky130_fd_sc_hd__tapvpwrvgnd_1
XFILLER_92_672 VGND VGND VPWR VPWR sky130_fd_sc_hd__decap_3
XFILLER_52_525 VGND VGND VPWR VPWR sky130_fd_sc_hd__decap_3
XTAP_TAPCELL_ROW_35_723 VGND VPWR sky130_fd_sc_hd__tapvpwrvgnd_1
XFILLER_52_536 VGND VGND VPWR VPWR sky130_fd_sc_hd__decap_3
XTAP_TAPCELL_ROW_82_1331 VGND VPWR sky130_fd_sc_hd__tapvpwrvgnd_1
X_4944_ _5010_/A _4944_/B _4944_/C VGND VGND VPWR VPWR _4944_/X sky130_fd_sc_hd__or3_2
X_4875_ _4842_/X _4871_/Y _4874_/X VGND VGND VPWR VPWR _5663_/C sky130_fd_sc_hd__a21bo_2
XFILLER_20_411 VGND VGND VPWR VPWR sky130_fd_sc_hd__decap_3
XFILLER_32_282 VGND VGND VPWR VPWR sky130_fd_sc_hd__decap_3
X_6614_ _6614_/A VGND VGND VPWR VPWR _6614_/Y sky130_fd_sc_hd__inv_2
X_3826_ _6731_/Q _3917_/A2 _3912_/B1 _6743_/Q _3825_/X VGND VGND VPWR VPWR _3826_/X
+ sky130_fd_sc_hd__a221o_2
X_6545_ _6650_/A VGND VGND VPWR VPWR _6545_/Y sky130_fd_sc_hd__inv_2
X_3757_ _3757_/A0 _3756_/X _4832_/A VGND VGND VPWR VPWR _7396_/D sky130_fd_sc_hd__mux2_2
XFILLER_118_332 VGND VGND VPWR VPWR sky130_fd_sc_hd__decap_3
X_6476_ _6544_/A VGND VGND VPWR VPWR _6476_/Y sky130_fd_sc_hd__inv_2
XFILLER_109_9 VGND VGND VPWR VPWR sky130_fd_sc_hd__decap_3
X_5427_ _5427_/A0 _5156_/X _5427_/S VGND VGND VPWR VPWR _7120_/D sky130_fd_sc_hd__mux2_2
XFILLER_121_508 VGND VGND VPWR VPWR sky130_fd_sc_hd__decap_3
XTAP_TAPCELL_ROW_93_1471 VGND VPWR sky130_fd_sc_hd__tapvpwrvgnd_1
XTAP_TAPCELL_ROW_93_1482 VGND VPWR sky130_fd_sc_hd__tapvpwrvgnd_1
XFILLER_114_560 VGND VGND VPWR VPWR sky130_fd_sc_hd__decap_3
X_5358_ _5358_/A0 _5156_/X _7412_/A VGND VGND VPWR VPWR _7152_/D sky130_fd_sc_hd__mux2_2
XFILLER_99_271 VGND VGND VPWR VPWR sky130_fd_sc_hd__decap_3
XFILLER_102_722 VGND VGND VPWR VPWR sky130_fd_sc_hd__decap_3
X_4309_ _7128_/Q _4351_/B1 _4307_/X _4308_/X VGND VGND VPWR VPWR _4311_/B sky130_fd_sc_hd__a211o_2
XFILLER_75_606 VGND VGND VPWR VPWR sky130_fd_sc_hd__decap_3
XFILLER_75_617 VGND VGND VPWR VPWR sky130_fd_sc_hd__decap_3
X_7028_ _7387_/CLK _7028_/D _6308_/Y VGND VGND VPWR VPWR _7028_/Q sky130_fd_sc_hd__dfrtp_2
XFILLER_74_105 VGND VGND VPWR VPWR sky130_fd_sc_hd__decap_3
XFILLER_47_319 VGND VGND VPWR VPWR sky130_fd_sc_hd__decap_3
XFILLER_114_44 VGND VGND VPWR VPWR sky130_fd_sc_hd__decap_3
XFILLER_74_127 VGND VGND VPWR VPWR sky130_fd_sc_hd__decap_3
XFILLER_74_15 VGND VGND VPWR VPWR sky130_fd_sc_hd__decap_3
XFILLER_28_533 VGND VGND VPWR VPWR sky130_fd_sc_hd__decap_3
XFILLER_28_544 VGND VGND VPWR VPWR sky130_fd_sc_hd__decap_3
XFILLER_114_77 VGND VGND VPWR VPWR sky130_fd_sc_hd__decap_3
XFILLER_114_88 VGND VGND VPWR VPWR sky130_fd_sc_hd__fill_2
XFILLER_83_650 VGND VGND VPWR VPWR sky130_fd_sc_hd__decap_3
XFILLER_28_577 VGND VGND VPWR VPWR sky130_fd_sc_hd__decap_3
XFILLER_16_728 VGND VGND VPWR VPWR sky130_fd_sc_hd__decap_3
XFILLER_82_160 VGND VGND VPWR VPWR sky130_fd_sc_hd__decap_3
XFILLER_83_694 VGND VGND VPWR VPWR sky130_fd_sc_hd__decap_3
XFILLER_82_182 VGND VGND VPWR VPWR sky130_fd_sc_hd__decap_3
XFILLER_55_396 VGND VGND VPWR VPWR sky130_fd_sc_hd__decap_3
XFILLER_70_333 VGND VGND VPWR VPWR sky130_fd_sc_hd__decap_3
XFILLER_43_558 VGND VGND VPWR VPWR sky130_fd_sc_hd__fill_2
XFILLER_31_709 VGND VGND VPWR VPWR sky130_fd_sc_hd__decap_3
XFILLER_70_388 VGND VGND VPWR VPWR sky130_fd_sc_hd__decap_3
XFILLER_30_219 VGND VGND VPWR VPWR sky130_fd_sc_hd__decap_3
XFILLER_11_411 VGND VGND VPWR VPWR sky130_fd_sc_hd__decap_3
XTAP_TAPCELL_ROW_13_439 VGND VPWR sky130_fd_sc_hd__tapvpwrvgnd_1
XFILLER_23_293 VGND VGND VPWR VPWR sky130_fd_sc_hd__fill_2
XFILLER_11_444 VGND VGND VPWR VPWR sky130_fd_sc_hd__decap_3
XFILLER_11_466 VGND VGND VPWR VPWR sky130_fd_sc_hd__decap_3
XFILLER_23_74 VGND VGND VPWR VPWR sky130_fd_sc_hd__fill_1
XFILLER_109_321 VGND VGND VPWR VPWR sky130_fd_sc_hd__decap_3
XFILLER_109_343 VGND VGND VPWR VPWR sky130_fd_sc_hd__decap_3
XFILLER_109_365 VGND VGND VPWR VPWR sky130_fd_sc_hd__decap_3
XFILLER_3_632 VGND VGND VPWR VPWR sky130_fd_sc_hd__decap_3
XFILLER_3_665 VGND VGND VPWR VPWR sky130_fd_sc_hd__decap_3
XFILLER_112_519 VGND VGND VPWR VPWR sky130_fd_sc_hd__decap_3
XFILLER_97_219 VGND VGND VPWR VPWR sky130_fd_sc_hd__decap_3
XFILLER_3_676 VGND VGND VPWR VPWR sky130_fd_sc_hd__decap_3
XFILLER_78_411 VGND VGND VPWR VPWR sky130_fd_sc_hd__fill_1
XFILLER_105_582 VGND VGND VPWR VPWR sky130_fd_sc_hd__decap_3
XFILLER_2_186 VGND VGND VPWR VPWR sky130_fd_sc_hd__decap_3
XFILLER_2_197 VGND VGND VPWR VPWR sky130_fd_sc_hd__decap_3
XFILLER_78_466 VGND VGND VPWR VPWR sky130_fd_sc_hd__decap_3
XFILLER_66_606 VGND VGND VPWR VPWR sky130_fd_sc_hd__decap_3
XFILLER_78_477 VGND VGND VPWR VPWR sky130_fd_sc_hd__decap_3
XFILLER_120_563 VGND VGND VPWR VPWR sky130_fd_sc_hd__decap_3
XFILLER_93_414 VGND VGND VPWR VPWR sky130_fd_sc_hd__decap_3
XFILLER_66_639 VGND VGND VPWR VPWR sky130_fd_sc_hd__decap_3
XFILLER_19_500 VGND VGND VPWR VPWR sky130_fd_sc_hd__decap_3
Xsingle_cycle_cpu_578 VGND VGND VPWR VPWR single_cycle_cpu_578/HI instruction_out[31]
+ sky130_fd_sc_hd__conb_1
XFILLER_19_511 VGND VGND VPWR VPWR sky130_fd_sc_hd__decap_3
XFILLER_59_691 VGND VGND VPWR VPWR sky130_fd_sc_hd__decap_3
XFILLER_81_609 VGND VGND VPWR VPWR sky130_fd_sc_hd__decap_3
XFILLER_46_330 VGND VGND VPWR VPWR sky130_fd_sc_hd__decap_3
XFILLER_80_119 VGND VGND VPWR VPWR sky130_fd_sc_hd__decap_3
XFILLER_74_672 VGND VGND VPWR VPWR sky130_fd_sc_hd__decap_3
XFILLER_19_588 VGND VGND VPWR VPWR sky130_fd_sc_hd__decap_3
XFILLER_34_514 VGND VGND VPWR VPWR sky130_fd_sc_hd__decap_3
XTAP_TAPCELL_ROW_105_1629 VGND VPWR sky130_fd_sc_hd__tapvpwrvgnd_1
XFILLER_64_70 VGND VGND VPWR VPWR sky130_fd_sc_hd__decap_3
XFILLER_34_558 VGND VGND VPWR VPWR sky130_fd_sc_hd__decap_3
XFILLER_61_366 VGND VGND VPWR VPWR sky130_fd_sc_hd__decap_3
XFILLER_21_208 VGND VGND VPWR VPWR sky130_fd_sc_hd__decap_3
XFILLER_21_219 VGND VGND VPWR VPWR sky130_fd_sc_hd__decap_3
XTAP_TAPCELL_ROW_64_1094 VGND VPWR sky130_fd_sc_hd__tapvpwrvgnd_1
XFILLER_30_731 VGND VGND VPWR VPWR sky130_fd_sc_hd__decap_3
XFILLER_9_76 VGND VGND VPWR VPWR sky130_fd_sc_hd__decap_3
X_4660_ _4720_/A _4655_/X _4658_/A VGND VGND VPWR VPWR _4660_/X sky130_fd_sc_hd__a21bo_2
X_3611_ _5057_/A _3611_/B VGND VGND VPWR VPWR _3611_/Y sky130_fd_sc_hd__nor2_2
XFILLER_80_91 VGND VGND VPWR VPWR sky130_fd_sc_hd__decap_3
XTAP_TAPCELL_ROW_40_781 VGND VPWR sky130_fd_sc_hd__tapvpwrvgnd_1
XTAP_TAPCELL_ROW_40_792 VGND VPWR sky130_fd_sc_hd__tapvpwrvgnd_1
X_4591_ _4591_/A _4595_/B VGND VGND VPWR VPWR _7285_/D sky130_fd_sc_hd__and2_2
X_6330_ _6650_/A VGND VGND VPWR VPWR _6330_/Y sky130_fd_sc_hd__inv_2
Xhold905 _6702_/Q VGND VGND VPWR VPWR hold905/X sky130_fd_sc_hd__dlygate4sd3_1
XFILLER_115_302 VGND VGND VPWR VPWR sky130_fd_sc_hd__decap_3
Xhold916 _6698_/Q VGND VGND VPWR VPWR hold916/X sky130_fd_sc_hd__dlygate4sd3_1
Xhold927 _7033_/Q VGND VGND VPWR VPWR _5589_/A sky130_fd_sc_hd__dlygate4sd3_1
XFILLER_6_481 VGND VGND VPWR VPWR sky130_fd_sc_hd__fill_2
XTAP_TAPCELL_ROW_116_1769 VGND VPWR sky130_fd_sc_hd__tapvpwrvgnd_1
Xhold938 _7042_/Q VGND VGND VPWR VPWR hold938/X sky130_fd_sc_hd__dlygate4sd3_1
X_3473_ _7312_/Q _3996_/S _3380_/Y _7344_/Q _3556_/A VGND VGND VPWR VPWR _3473_/X
+ sky130_fd_sc_hd__a221o_2
X_6261_ _6660_/A VGND VGND VPWR VPWR _6261_/Y sky130_fd_sc_hd__inv_2
Xhold949 _7028_/Q VGND VGND VPWR VPWR hold949/X sky130_fd_sc_hd__dlygate4sd3_1
XFILLER_89_709 VGND VGND VPWR VPWR sky130_fd_sc_hd__decap_3
XFILLER_115_346 VGND VGND VPWR VPWR sky130_fd_sc_hd__fill_2
XFILLER_115_379 VGND VGND VPWR VPWR sky130_fd_sc_hd__decap_3
XFILLER_69_411 VGND VGND VPWR VPWR sky130_fd_sc_hd__decap_3
XFILLER_96_230 VGND VGND VPWR VPWR sky130_fd_sc_hd__decap_3
XFILLER_69_455 VGND VGND VPWR VPWR sky130_fd_sc_hd__decap_3
XFILLER_111_552 VGND VGND VPWR VPWR sky130_fd_sc_hd__decap_3
XFILLER_57_617 VGND VGND VPWR VPWR sky130_fd_sc_hd__decap_3
XFILLER_84_403 VGND VGND VPWR VPWR sky130_fd_sc_hd__decap_3
X_5074_ _4852_/A _5073_/A _5073_/Y _4811_/C VGND VGND VPWR VPWR _5075_/C sky130_fd_sc_hd__a2bb2o_2
XFILLER_56_105 VGND VGND VPWR VPWR sky130_fd_sc_hd__decap_3
XFILLER_111_585 VGND VGND VPWR VPWR sky130_fd_sc_hd__decap_3
XFILLER_96_296 VGND VGND VPWR VPWR sky130_fd_sc_hd__decap_3
XFILLER_84_436 VGND VGND VPWR VPWR sky130_fd_sc_hd__fill_1
XFILLER_56_127 VGND VGND VPWR VPWR sky130_fd_sc_hd__decap_3
XFILLER_84_458 VGND VGND VPWR VPWR sky130_fd_sc_hd__decap_3
XFILLER_65_650 VGND VGND VPWR VPWR sky130_fd_sc_hd__decap_3
XFILLER_37_352 VGND VGND VPWR VPWR sky130_fd_sc_hd__decap_3
XFILLER_65_694 VGND VGND VPWR VPWR sky130_fd_sc_hd__decap_3
XFILLER_25_525 VGND VGND VPWR VPWR sky130_fd_sc_hd__fill_1
XTAP_TAPCELL_ROW_48_892 VGND VPWR sky130_fd_sc_hd__tapvpwrvgnd_1
XFILLER_80_631 VGND VGND VPWR VPWR sky130_fd_sc_hd__decap_3
XFILLER_44_29 VGND VGND VPWR VPWR sky130_fd_sc_hd__decap_3
XFILLER_25_547 VGND VGND VPWR VPWR sky130_fd_sc_hd__fill_2
XFILLER_52_355 VGND VGND VPWR VPWR sky130_fd_sc_hd__fill_1
XFILLER_13_709 VGND VGND VPWR VPWR sky130_fd_sc_hd__decap_3
XFILLER_80_675 VGND VGND VPWR VPWR sky130_fd_sc_hd__decap_3
XFILLER_52_377 VGND VGND VPWR VPWR sky130_fd_sc_hd__fill_1
XFILLER_40_528 VGND VGND VPWR VPWR sky130_fd_sc_hd__decap_3
X_4927_ _4983_/A _4927_/B _5656_/C VGND VGND VPWR VPWR _4927_/X sky130_fd_sc_hd__or3_2
X_4858_ _6999_/Q _4858_/B VGND VGND VPWR VPWR _4870_/A sky130_fd_sc_hd__and2_2
XFILLER_100_79 VGND VGND VPWR VPWR sky130_fd_sc_hd__decap_3
XFILLER_20_274 VGND VGND VPWR VPWR sky130_fd_sc_hd__decap_3
X_3809_ _6836_/Q _3891_/A2 _3891_/B1 _6841_/Q VGND VGND VPWR VPWR _3809_/X sky130_fd_sc_hd__a22o_2
XFILLER_119_641 VGND VGND VPWR VPWR sky130_fd_sc_hd__decap_3
XTAP_TAPCELL_ROW_95_1500 VGND VPWR sky130_fd_sc_hd__tapvpwrvgnd_1
X_4789_ _5057_/A _4412_/B _4413_/A _4852_/A _4788_/Y VGND VGND VPWR VPWR _4789_/X
+ sky130_fd_sc_hd__o221a_2
X_6528_ _6633_/A VGND VGND VPWR VPWR _6528_/Y sky130_fd_sc_hd__inv_2
XFILLER_119_685 VGND VGND VPWR VPWR sky130_fd_sc_hd__decap_3
XFILLER_118_151 VGND VGND VPWR VPWR sky130_fd_sc_hd__decap_3
XFILLER_109_33 VGND VGND VPWR VPWR sky130_fd_sc_hd__decap_3
XFILLER_106_324 VGND VGND VPWR VPWR sky130_fd_sc_hd__decap_3
XFILLER_69_15 VGND VGND VPWR VPWR sky130_fd_sc_hd__decap_3
XFILLER_107_6 VGND VGND VPWR VPWR sky130_fd_sc_hd__fill_1
X_6459_ _6620_/A VGND VGND VPWR VPWR _6459_/Y sky130_fd_sc_hd__inv_2
XFILLER_69_48 VGND VGND VPWR VPWR sky130_fd_sc_hd__decap_3
XFILLER_79_219 VGND VGND VPWR VPWR sky130_fd_sc_hd__decap_3
XFILLER_88_731 VGND VGND VPWR VPWR sky130_fd_sc_hd__decap_3
XFILLER_0_635 VGND VGND VPWR VPWR sky130_fd_sc_hd__decap_3
XFILLER_48_606 VGND VGND VPWR VPWR sky130_fd_sc_hd__decap_3
XFILLER_0_668 VGND VGND VPWR VPWR sky130_fd_sc_hd__decap_3
XFILLER_102_563 VGND VGND VPWR VPWR sky130_fd_sc_hd__decap_3
XFILLER_85_25 VGND VGND VPWR VPWR sky130_fd_sc_hd__decap_3
XFILLER_48_639 VGND VGND VPWR VPWR sky130_fd_sc_hd__decap_3
XFILLER_47_116 VGND VGND VPWR VPWR sky130_fd_sc_hd__decap_3
XFILLER_85_69 VGND VGND VPWR VPWR sky130_fd_sc_hd__fill_1
XFILLER_28_330 VGND VGND VPWR VPWR sky130_fd_sc_hd__decap_3
XFILLER_90_417 VGND VGND VPWR VPWR sky130_fd_sc_hd__decap_3
XFILLER_56_672 VGND VGND VPWR VPWR sky130_fd_sc_hd__decap_3
XFILLER_28_363 VGND VGND VPWR VPWR sky130_fd_sc_hd__fill_1
XFILLER_18_74 VGND VGND VPWR VPWR sky130_fd_sc_hd__decap_3
XFILLER_28_374 VGND VGND VPWR VPWR sky130_fd_sc_hd__decap_3
XFILLER_16_525 VGND VGND VPWR VPWR sky130_fd_sc_hd__fill_2
XFILLER_71_620 VGND VGND VPWR VPWR sky130_fd_sc_hd__decap_3
XFILLER_18_96 VGND VGND VPWR VPWR sky130_fd_sc_hd__fill_2
XFILLER_83_491 VGND VGND VPWR VPWR sky130_fd_sc_hd__decap_3
XFILLER_43_322 VGND VGND VPWR VPWR sky130_fd_sc_hd__decap_3
XFILLER_71_653 VGND VGND VPWR VPWR sky130_fd_sc_hd__decap_3
XFILLER_16_558 VGND VGND VPWR VPWR sky130_fd_sc_hd__decap_3
XFILLER_70_141 VGND VGND VPWR VPWR sky130_fd_sc_hd__decap_3
XFILLER_43_377 VGND VGND VPWR VPWR sky130_fd_sc_hd__decap_3
XFILLER_71_697 VGND VGND VPWR VPWR sky130_fd_sc_hd__decap_3
XFILLER_43_388 VGND VGND VPWR VPWR sky130_fd_sc_hd__fill_1
XFILLER_70_174 VGND VGND VPWR VPWR sky130_fd_sc_hd__decap_3
XFILLER_70_185 VGND VGND VPWR VPWR sky130_fd_sc_hd__decap_3
XFILLER_12_731 VGND VGND VPWR VPWR sky130_fd_sc_hd__decap_3
XFILLER_11_230 VGND VGND VPWR VPWR sky130_fd_sc_hd__decap_3
XFILLER_8_713 VGND VGND VPWR VPWR sky130_fd_sc_hd__decap_3
XFILLER_7_223 VGND VGND VPWR VPWR sky130_fd_sc_hd__fill_1
XFILLER_7_278 VGND VGND VPWR VPWR sky130_fd_sc_hd__fill_2
XPHY_EDGE_ROW_84_Left_208 VGND VGND VPWR VPWR sky130_fd_sc_hd__decap_3
XFILLER_3_473 VGND VGND VPWR VPWR sky130_fd_sc_hd__decap_3
XFILLER_3_495 VGND VGND VPWR VPWR sky130_fd_sc_hd__decap_3
XFILLER_78_230 VGND VGND VPWR VPWR sky130_fd_sc_hd__decap_3
XFILLER_94_701 VGND VGND VPWR VPWR sky130_fd_sc_hd__decap_3
XFILLER_39_617 VGND VGND VPWR VPWR sky130_fd_sc_hd__decap_3
XFILLER_38_105 VGND VGND VPWR VPWR sky130_fd_sc_hd__decap_3
XFILLER_120_360 VGND VGND VPWR VPWR sky130_fd_sc_hd__decap_3
XFILLER_93_200 VGND VGND VPWR VPWR sky130_fd_sc_hd__decap_3
XFILLER_94_734 VGND VGND VPWR VPWR sky130_fd_sc_hd__fill_1
XFILLER_120_371 VGND VGND VPWR VPWR sky130_fd_sc_hd__decap_3
XFILLER_78_296 VGND VGND VPWR VPWR sky130_fd_sc_hd__decap_3
XFILLER_38_138 VGND VGND VPWR VPWR sky130_fd_sc_hd__fill_2
XFILLER_47_650 VGND VGND VPWR VPWR sky130_fd_sc_hd__decap_3
XFILLER_93_266 VGND VGND VPWR VPWR sky130_fd_sc_hd__fill_2
XFILLER_53_108 VGND VGND VPWR VPWR sky130_fd_sc_hd__decap_3
XFILLER_75_91 VGND VGND VPWR VPWR sky130_fd_sc_hd__decap_3
XFILLER_34_300 VGND VGND VPWR VPWR sky130_fd_sc_hd__decap_3
XFILLER_19_374 VGND VGND VPWR VPWR sky130_fd_sc_hd__decap_3
XFILLER_62_620 VGND VGND VPWR VPWR sky130_fd_sc_hd__decap_3
XFILLER_47_694 VGND VGND VPWR VPWR sky130_fd_sc_hd__decap_3
XTAP_TAPCELL_ROW_66_1123 VGND VPWR sky130_fd_sc_hd__tapvpwrvgnd_1
XFILLER_19_396 VGND VGND VPWR VPWR sky130_fd_sc_hd__decap_3
XPHY_EDGE_ROW_93_Left_217 VGND VGND VPWR VPWR sky130_fd_sc_hd__decap_3
XFILLER_46_182 VGND VGND VPWR VPWR sky130_fd_sc_hd__decap_3
XTAP_TAPCELL_ROW_45_851 VGND VPWR sky130_fd_sc_hd__tapvpwrvgnd_1
XFILLER_34_355 VGND VGND VPWR VPWR sky130_fd_sc_hd__fill_2
XFILLER_62_675 VGND VGND VPWR VPWR sky130_fd_sc_hd__decap_3
XFILLER_34_377 VGND VGND VPWR VPWR sky130_fd_sc_hd__decap_3
XFILLER_61_163 VGND VGND VPWR VPWR sky130_fd_sc_hd__decap_3
XFILLER_22_539 VGND VGND VPWR VPWR sky130_fd_sc_hd__decap_3
XFILLER_15_591 VGND VGND VPWR VPWR sky130_fd_sc_hd__decap_3
X_4712_ _7007_/Q _4738_/A VGND VGND VPWR VPWR _4731_/B sky130_fd_sc_hd__nand2_2
XFILLER_30_550 VGND VGND VPWR VPWR sky130_fd_sc_hd__decap_3
XFILLER_30_572 VGND VGND VPWR VPWR sky130_fd_sc_hd__decap_3
X_4643_ _4888_/A _4125_/X _4126_/A VGND VGND VPWR VPWR _4643_/Y sky130_fd_sc_hd__a21oi_2
X_7362_ _7362_/CLK _7362_/D _6642_/Y VGND VGND VPWR VPWR _7362_/Q sky130_fd_sc_hd__dfrtp_2
Xhold702 _6738_/Q VGND VGND VPWR VPWR _6738_/D sky130_fd_sc_hd__dlygate4sd3_1
XFILLER_116_622 VGND VGND VPWR VPWR sky130_fd_sc_hd__decap_3
Xhold713 _6884_/Q VGND VGND VPWR VPWR _6884_/D sky130_fd_sc_hd__dlygate4sd3_1
X_6313_ _6591_/A VGND VGND VPWR VPWR _6313_/Y sky130_fd_sc_hd__inv_2
Xhold724 _6910_/Q VGND VGND VPWR VPWR _6910_/D sky130_fd_sc_hd__dlygate4sd3_1
XTAP_TAPCELL_ROW_77_1263 VGND VPWR sky130_fd_sc_hd__tapvpwrvgnd_1
X_3525_ _3525_/A _3525_/B VGND VGND VPWR VPWR _5114_/A sky130_fd_sc_hd__and2_2
Xhold735 _6949_/Q VGND VGND VPWR VPWR _6949_/D sky130_fd_sc_hd__dlygate4sd3_1
XTAP_TAPCELL_ROW_77_1274 VGND VPWR sky130_fd_sc_hd__tapvpwrvgnd_1
Xhold746 _6835_/Q VGND VGND VPWR VPWR _6835_/D sky130_fd_sc_hd__dlygate4sd3_1
X_7293_ _7359_/CLK _7293_/D _6573_/Y VGND VGND VPWR VPWR _7293_/Q sky130_fd_sc_hd__dfrtp_2
XFILLER_116_666 VGND VGND VPWR VPWR sky130_fd_sc_hd__decap_3
XFILLER_115_143 VGND VGND VPWR VPWR sky130_fd_sc_hd__decap_3
Xhold757 _6868_/Q VGND VGND VPWR VPWR _6868_/D sky130_fd_sc_hd__dlygate4sd3_1
Xhold768 _6811_/Q VGND VGND VPWR VPWR _6811_/D sky130_fd_sc_hd__dlygate4sd3_1
XFILLER_103_305 VGND VGND VPWR VPWR sky130_fd_sc_hd__decap_3
XPHY_EDGE_ROW_123_Right_123 VGND VGND VPWR VPWR sky130_fd_sc_hd__decap_3
Xhold779 _6807_/Q VGND VGND VPWR VPWR _6807_/D sky130_fd_sc_hd__dlygate4sd3_1
XFILLER_116_699 VGND VGND VPWR VPWR sky130_fd_sc_hd__fill_1
X_3456_ _7011_/Q _4601_/S _3448_/X _3455_/X VGND VGND VPWR VPWR _3456_/X sky130_fd_sc_hd__a211o_2
XFILLER_103_327 VGND VGND VPWR VPWR sky130_fd_sc_hd__fill_1
XTAP_TAPCELL_ROW_90_1441 VGND VPWR sky130_fd_sc_hd__tapvpwrvgnd_1
XFILLER_103_349 VGND VGND VPWR VPWR sky130_fd_sc_hd__decap_3
X_3387_ _3385_/Y _3386_/Y _3977_/S _3399_/B VGND VGND VPWR VPWR _3429_/B sky130_fd_sc_hd__a211o_2
XFILLER_97_550 VGND VGND VPWR VPWR sky130_fd_sc_hd__decap_3
XFILLER_97_561 VGND VGND VPWR VPWR sky130_fd_sc_hd__decap_3
XFILLER_69_252 VGND VGND VPWR VPWR sky130_fd_sc_hd__decap_3
XFILLER_85_712 VGND VGND VPWR VPWR sky130_fd_sc_hd__decap_3
X_5126_ _5126_/A0 _5125_/Y _5159_/S VGND VGND VPWR VPWR _7253_/D sky130_fd_sc_hd__mux2_2
XFILLER_84_200 VGND VGND VPWR VPWR sky130_fd_sc_hd__fill_1
XFILLER_57_414 VGND VGND VPWR VPWR sky130_fd_sc_hd__decap_3
XFILLER_97_594 VGND VGND VPWR VPWR sky130_fd_sc_hd__decap_3
XFILLER_84_211 VGND VGND VPWR VPWR sky130_fd_sc_hd__decap_3
XFILLER_69_296 VGND VGND VPWR VPWR sky130_fd_sc_hd__decap_3
XFILLER_111_393 VGND VGND VPWR VPWR sky130_fd_sc_hd__decap_3
XFILLER_84_244 VGND VGND VPWR VPWR sky130_fd_sc_hd__decap_3
X_5057_ _5057_/A _5057_/B VGND VGND VPWR VPWR _5057_/Y sky130_fd_sc_hd__nor2_2
XFILLER_84_266 VGND VGND VPWR VPWR sky130_fd_sc_hd__decap_3
XFILLER_72_406 VGND VGND VPWR VPWR sky130_fd_sc_hd__fill_2
XFILLER_38_672 VGND VGND VPWR VPWR sky130_fd_sc_hd__decap_3
XFILLER_53_620 VGND VGND VPWR VPWR sky130_fd_sc_hd__decap_3
XFILLER_111_12 VGND VGND VPWR VPWR sky130_fd_sc_hd__decap_3
XFILLER_53_653 VGND VGND VPWR VPWR sky130_fd_sc_hd__decap_3
XFILLER_52_141 VGND VGND VPWR VPWR sky130_fd_sc_hd__decap_3
XFILLER_111_45 VGND VGND VPWR VPWR sky130_fd_sc_hd__decap_3
XFILLER_25_377 VGND VGND VPWR VPWR sky130_fd_sc_hd__decap_3
XFILLER_53_697 VGND VGND VPWR VPWR sky130_fd_sc_hd__decap_3
XFILLER_71_27 VGND VGND VPWR VPWR sky130_fd_sc_hd__decap_3
XTAP_TAPCELL_ROW_23_567 VGND VPWR sky130_fd_sc_hd__tapvpwrvgnd_1
XFILLER_21_561 VGND VGND VPWR VPWR sky130_fd_sc_hd__fill_2
XFILLER_21_583 VGND VGND VPWR VPWR sky130_fd_sc_hd__decap_3
XFILLER_107_600 VGND VGND VPWR VPWR sky130_fd_sc_hd__decap_3
XFILLER_5_727 VGND VGND VPWR VPWR sky130_fd_sc_hd__fill_1
XFILLER_119_460 VGND VGND VPWR VPWR sky130_fd_sc_hd__decap_3
XFILLER_4_215 VGND VGND VPWR VPWR sky130_fd_sc_hd__decap_3
XFILLER_119_493 VGND VGND VPWR VPWR sky130_fd_sc_hd__decap_3
XFILLER_107_644 VGND VGND VPWR VPWR sky130_fd_sc_hd__decap_3
XFILLER_4_248 VGND VGND VPWR VPWR sky130_fd_sc_hd__decap_3
XFILLER_105_3 VGND VGND VPWR VPWR sky130_fd_sc_hd__decap_3
XFILLER_4_259 VGND VGND VPWR VPWR sky130_fd_sc_hd__decap_3
XFILLER_107_688 VGND VGND VPWR VPWR sky130_fd_sc_hd__decap_3
XFILLER_122_625 VGND VGND VPWR VPWR sky130_fd_sc_hd__decap_3
XFILLER_121_102 VGND VGND VPWR VPWR sky130_fd_sc_hd__decap_3
XFILLER_121_113 VGND VGND VPWR VPWR sky130_fd_sc_hd__decap_3
XFILLER_96_35 VGND VGND VPWR VPWR sky130_fd_sc_hd__fill_1
XFILLER_122_669 VGND VGND VPWR VPWR sky130_fd_sc_hd__decap_3
XFILLER_88_550 VGND VGND VPWR VPWR sky130_fd_sc_hd__decap_3
XFILLER_76_701 VGND VGND VPWR VPWR sky130_fd_sc_hd__decap_3
XFILLER_88_583 VGND VGND VPWR VPWR sky130_fd_sc_hd__decap_3
XFILLER_76_734 VGND VGND VPWR VPWR sky130_fd_sc_hd__fill_1
XFILLER_102_371 VGND VGND VPWR VPWR sky130_fd_sc_hd__decap_3
XFILLER_29_73 VGND VGND VPWR VPWR sky130_fd_sc_hd__decap_3
XFILLER_48_469 VGND VGND VPWR VPWR sky130_fd_sc_hd__decap_3
XFILLER_91_715 VGND VGND VPWR VPWR sky130_fd_sc_hd__decap_3
XFILLER_29_650 VGND VGND VPWR VPWR sky130_fd_sc_hd__decap_3
XFILLER_75_277 VGND VGND VPWR VPWR sky130_fd_sc_hd__decap_3
XFILLER_90_214 VGND VGND VPWR VPWR sky130_fd_sc_hd__decap_3
XFILLER_63_428 VGND VGND VPWR VPWR sky130_fd_sc_hd__decap_3
XFILLER_35_119 VGND VGND VPWR VPWR sky130_fd_sc_hd__decap_3
Xplace406 _3488_/B VGND VGND VPWR VPWR _4534_/S sky130_fd_sc_hd__buf_2
XFILLER_56_480 VGND VGND VPWR VPWR sky130_fd_sc_hd__decap_3
XFILLER_29_694 VGND VGND VPWR VPWR sky130_fd_sc_hd__decap_3
Xplace417 _3380_/Y VGND VGND VPWR VPWR _4268_/B1 sky130_fd_sc_hd__buf_2
Xplace428 _3966_/S VGND VGND VPWR VPWR _3958_/S sky130_fd_sc_hd__buf_2
XFILLER_44_642 VGND VGND VPWR VPWR sky130_fd_sc_hd__fill_2
XFILLER_16_333 VGND VGND VPWR VPWR sky130_fd_sc_hd__decap_3
Xplace439 _5015_/A VGND VGND VPWR VPWR _4983_/A sky130_fd_sc_hd__buf_2
XFILLER_16_355 VGND VGND VPWR VPWR sky130_fd_sc_hd__decap_3
XFILLER_44_675 VGND VGND VPWR VPWR sky130_fd_sc_hd__decap_3
XFILLER_43_163 VGND VGND VPWR VPWR sky130_fd_sc_hd__fill_1
XTAP_TAPCELL_ROW_42_810 VGND VPWR sky130_fd_sc_hd__tapvpwrvgnd_1
XFILLER_31_314 VGND VGND VPWR VPWR sky130_fd_sc_hd__decap_3
XFILLER_16_388 VGND VGND VPWR VPWR sky130_fd_sc_hd__decap_3
XFILLER_43_174 VGND VGND VPWR VPWR sky130_fd_sc_hd__decap_3
XFILLER_12_550 VGND VGND VPWR VPWR sky130_fd_sc_hd__decap_3
XFILLER_8_510 VGND VGND VPWR VPWR sky130_fd_sc_hd__decap_3
XTAP_TAPCELL_ROW_61_1064 VGND VPWR sky130_fd_sc_hd__tapvpwrvgnd_1
XFILLER_12_583 VGND VGND VPWR VPWR sky130_fd_sc_hd__decap_3
XFILLER_8_554 VGND VGND VPWR VPWR sky130_fd_sc_hd__decap_3
XFILLER_117_408 VGND VGND VPWR VPWR sky130_fd_sc_hd__decap_3
XFILLER_8_587 VGND VGND VPWR VPWR sky130_fd_sc_hd__fill_1
XFILLER_8_598 VGND VGND VPWR VPWR sky130_fd_sc_hd__decap_3
XANTENNA_4 _3331_/A VGND VGND VPWR VPWR sky130_fd_sc_hd__diode_2
XFILLER_6_88 VGND VGND VPWR VPWR sky130_fd_sc_hd__fill_2
XFILLER_113_603 VGND VGND VPWR VPWR sky130_fd_sc_hd__decap_3
XTAP_TAPCELL_ROW_113_1739 VGND VPWR sky130_fd_sc_hd__tapvpwrvgnd_1
X_3310_ _5118_/C _3519_/B _3383_/B _5129_/A VGND VGND VPWR VPWR _3310_/Y sky130_fd_sc_hd__a31oi_2
X_4290_ _4283_/X _4288_/X _5647_/B _4649_/A VGND VGND VPWR VPWR _4612_/B sky130_fd_sc_hd__a2bb2o_4
XFILLER_113_647 VGND VGND VPWR VPWR sky130_fd_sc_hd__decap_3
XFILLER_3_281 VGND VGND VPWR VPWR sky130_fd_sc_hd__decap_3
XFILLER_79_561 VGND VGND VPWR VPWR sky130_fd_sc_hd__decap_3
XFILLER_112_168 VGND VGND VPWR VPWR sky130_fd_sc_hd__fill_1
XFILLER_67_712 VGND VGND VPWR VPWR sky130_fd_sc_hd__decap_3
XFILLER_79_594 VGND VGND VPWR VPWR sky130_fd_sc_hd__decap_3
XFILLER_94_531 VGND VGND VPWR VPWR sky130_fd_sc_hd__fill_1
XFILLER_66_222 VGND VGND VPWR VPWR sky130_fd_sc_hd__decap_3
XFILLER_121_691 VGND VGND VPWR VPWR sky130_fd_sc_hd__decap_3
XFILLER_82_704 VGND VGND VPWR VPWR sky130_fd_sc_hd__decap_3
XFILLER_94_586 VGND VGND VPWR VPWR sky130_fd_sc_hd__fill_2
XFILLER_26_108 VGND VGND VPWR VPWR sky130_fd_sc_hd__decap_3
X_6931_ _6942_/CLK _6931_/D VGND VGND VPWR VPWR _6931_/Q sky130_fd_sc_hd__dfxtp_2
XFILLER_81_214 VGND VGND VPWR VPWR sky130_fd_sc_hd__decap_3
XFILLER_54_439 VGND VGND VPWR VPWR sky130_fd_sc_hd__fill_1
XFILLER_81_225 VGND VGND VPWR VPWR sky130_fd_sc_hd__decap_3
XFILLER_35_620 VGND VGND VPWR VPWR sky130_fd_sc_hd__decap_3
XFILLER_47_491 VGND VGND VPWR VPWR sky130_fd_sc_hd__fill_1
XFILLER_81_258 VGND VGND VPWR VPWR sky130_fd_sc_hd__decap_3
XFILLER_35_653 VGND VGND VPWR VPWR sky130_fd_sc_hd__decap_3
XFILLER_34_130 VGND VGND VPWR VPWR sky130_fd_sc_hd__fill_2
X_6862_ _6960_/CLK _6862_/D VGND VGND VPWR VPWR _6862_/Q sky130_fd_sc_hd__dfxtp_2
XFILLER_81_269 VGND VGND VPWR VPWR sky130_fd_sc_hd__decap_3
XFILLER_50_601 VGND VGND VPWR VPWR sky130_fd_sc_hd__decap_3
XFILLER_62_472 VGND VGND VPWR VPWR sky130_fd_sc_hd__decap_3
XFILLER_22_303 VGND VGND VPWR VPWR sky130_fd_sc_hd__decap_3
XFILLER_35_697 VGND VGND VPWR VPWR sky130_fd_sc_hd__decap_3
XFILLER_50_634 VGND VGND VPWR VPWR sky130_fd_sc_hd__decap_3
XFILLER_22_325 VGND VGND VPWR VPWR sky130_fd_sc_hd__decap_3
X_6793_ clkload8/A _6793_/D VGND VGND VPWR VPWR _6793_/Q sky130_fd_sc_hd__dfxtp_2
XFILLER_50_645 VGND VGND VPWR VPWR sky130_fd_sc_hd__decap_3
XFILLER_22_347 VGND VGND VPWR VPWR sky130_fd_sc_hd__decap_3
XFILLER_50_678 VGND VGND VPWR VPWR sky130_fd_sc_hd__decap_3
XTAP_TAPCELL_ROW_20_526 VGND VPWR sky130_fd_sc_hd__tapvpwrvgnd_1
XFILLER_30_380 VGND VGND VPWR VPWR sky130_fd_sc_hd__decap_3
XFILLER_108_408 VGND VGND VPWR VPWR sky130_fd_sc_hd__decap_3
X_4626_ _4256_/C _4626_/B _4626_/C VGND VGND VPWR VPWR _4626_/X sky130_fd_sc_hd__and3b_2
X_7345_ _7345_/CLK _7345_/D _6625_/Y VGND VGND VPWR VPWR _7345_/Q sky130_fd_sc_hd__dfrtp_2
XFILLER_2_719 VGND VGND VPWR VPWR sky130_fd_sc_hd__decap_3
XFILLER_116_463 VGND VGND VPWR VPWR sky130_fd_sc_hd__decap_3
X_3508_ _3508_/A _3508_/B VGND VGND VPWR VPWR _3508_/Y sky130_fd_sc_hd__nor2_2
XFILLER_89_314 VGND VGND VPWR VPWR sky130_fd_sc_hd__fill_1
XFILLER_1_218 VGND VGND VPWR VPWR sky130_fd_sc_hd__fill_1
XFILLER_104_625 VGND VGND VPWR VPWR sky130_fd_sc_hd__decap_3
X_7276_ _7372_/CLK _7276_/D _6556_/Y VGND VGND VPWR VPWR _7276_/Q sky130_fd_sc_hd__dfrtp_2
X_4488_ _4488_/A0 _7303_/Q _4488_/S VGND VGND VPWR VPWR _7335_/D sky130_fd_sc_hd__mux2_2
XFILLER_103_113 VGND VGND VPWR VPWR sky130_fd_sc_hd__fill_1
Xhold587 _6904_/Q VGND VGND VPWR VPWR _6904_/D sky130_fd_sc_hd__dlygate4sd3_1
Xhold598 _6927_/Q VGND VGND VPWR VPWR _6927_/D sky130_fd_sc_hd__dlygate4sd3_1
XFILLER_106_12 VGND VGND VPWR VPWR sky130_fd_sc_hd__decap_3
XFILLER_104_669 VGND VGND VPWR VPWR sky130_fd_sc_hd__decap_3
X_3439_ _7282_/Q _4532_/S _4348_/A2 _7154_/Q _3438_/X VGND VGND VPWR VPWR _3439_/X
+ sky130_fd_sc_hd__a221o_2
XFILLER_58_701 VGND VGND VPWR VPWR sky130_fd_sc_hd__decap_3
XFILLER_57_200 VGND VGND VPWR VPWR sky130_fd_sc_hd__decap_3
XFILLER_66_27 VGND VGND VPWR VPWR sky130_fd_sc_hd__fill_1
XFILLER_58_734 VGND VGND VPWR VPWR sky130_fd_sc_hd__fill_1
Xhold1210 _7326_/Q VGND VGND VPWR VPWR _4507_/A0 sky130_fd_sc_hd__dlygate4sd3_1
XFILLER_66_38 VGND VGND VPWR VPWR sky130_fd_sc_hd__decap_3
XFILLER_85_553 VGND VGND VPWR VPWR sky130_fd_sc_hd__decap_3
XFILLER_111_190 VGND VGND VPWR VPWR sky130_fd_sc_hd__decap_3
XFILLER_85_564 VGND VGND VPWR VPWR sky130_fd_sc_hd__decap_3
XFILLER_57_255 VGND VGND VPWR VPWR sky130_fd_sc_hd__decap_3
XFILLER_73_715 VGND VGND VPWR VPWR sky130_fd_sc_hd__decap_3
XFILLER_57_266 VGND VGND VPWR VPWR sky130_fd_sc_hd__decap_3
XFILLER_122_11 VGND VGND VPWR VPWR sky130_fd_sc_hd__decap_3
XFILLER_85_597 VGND VGND VPWR VPWR sky130_fd_sc_hd__decap_3
XFILLER_17_119 VGND VGND VPWR VPWR sky130_fd_sc_hd__fill_2
XTAP_TAPCELL_ROW_28_626 VGND VPWR sky130_fd_sc_hd__tapvpwrvgnd_1
XFILLER_122_44 VGND VGND VPWR VPWR sky130_fd_sc_hd__decap_3
XTAP_TAPCELL_ROW_28_637 VGND VPWR sky130_fd_sc_hd__tapvpwrvgnd_1
XFILLER_72_236 VGND VGND VPWR VPWR sky130_fd_sc_hd__decap_3
XFILLER_26_631 VGND VGND VPWR VPWR sky130_fd_sc_hd__decap_3
XFILLER_82_15 VGND VGND VPWR VPWR sky130_fd_sc_hd__decap_3
XTAP_TAPCELL_ROW_0_251 VGND VPWR sky130_fd_sc_hd__tapvpwrvgnd_1
XFILLER_122_77 VGND VGND VPWR VPWR sky130_fd_sc_hd__decap_3
XTAP_TAPCELL_ROW_0_262 VGND VPWR sky130_fd_sc_hd__tapvpwrvgnd_1
XFILLER_72_269 VGND VGND VPWR VPWR sky130_fd_sc_hd__decap_3
XFILLER_122_88 VGND VGND VPWR VPWR sky130_fd_sc_hd__decap_3
XFILLER_26_675 VGND VGND VPWR VPWR sky130_fd_sc_hd__decap_3
XTAP_TAPCELL_ROW_0_273 VGND VPWR sky130_fd_sc_hd__tapvpwrvgnd_1
XFILLER_41_601 VGND VGND VPWR VPWR sky130_fd_sc_hd__decap_3
XFILLER_41_623 VGND VGND VPWR VPWR sky130_fd_sc_hd__decap_3
XFILLER_80_280 VGND VGND VPWR VPWR sky130_fd_sc_hd__decap_3
XFILLER_41_656 VGND VGND VPWR VPWR sky130_fd_sc_hd__decap_3
XFILLER_40_133 VGND VGND VPWR VPWR sky130_fd_sc_hd__decap_3
XFILLER_31_63 VGND VGND VPWR VPWR sky130_fd_sc_hd__fill_1
XFILLER_5_546 VGND VGND VPWR VPWR sky130_fd_sc_hd__decap_3
XFILLER_119_290 VGND VGND VPWR VPWR sky130_fd_sc_hd__fill_1
XFILLER_107_452 VGND VGND VPWR VPWR sky130_fd_sc_hd__fill_2
XFILLER_5_579 VGND VGND VPWR VPWR sky130_fd_sc_hd__decap_3
XFILLER_107_463 VGND VGND VPWR VPWR sky130_fd_sc_hd__decap_3
XFILLER_122_444 VGND VGND VPWR VPWR sky130_fd_sc_hd__decap_3
XTAP_TAPCELL_ROW_8_373 VGND VPWR sky130_fd_sc_hd__tapvpwrvgnd_1
XFILLER_122_477 VGND VGND VPWR VPWR sky130_fd_sc_hd__decap_3
XFILLER_0_251 VGND VGND VPWR VPWR sky130_fd_sc_hd__fill_1
XFILLER_49_712 VGND VGND VPWR VPWR sky130_fd_sc_hd__decap_3
XFILLER_110_628 VGND VGND VPWR VPWR sky130_fd_sc_hd__decap_3
XFILLER_88_380 VGND VGND VPWR VPWR sky130_fd_sc_hd__decap_3
XFILLER_103_691 VGND VGND VPWR VPWR sky130_fd_sc_hd__decap_3
XFILLER_0_284 VGND VGND VPWR VPWR sky130_fd_sc_hd__fill_1
XFILLER_64_704 VGND VGND VPWR VPWR sky130_fd_sc_hd__decap_3
XFILLER_91_534 VGND VGND VPWR VPWR sky130_fd_sc_hd__fill_1
XFILLER_17_620 VGND VGND VPWR VPWR sky130_fd_sc_hd__decap_3
XFILLER_91_556 VGND VGND VPWR VPWR sky130_fd_sc_hd__decap_3
XFILLER_91_567 VGND VGND VPWR VPWR sky130_fd_sc_hd__decap_3
XFILLER_63_258 VGND VGND VPWR VPWR sky130_fd_sc_hd__fill_2
XFILLER_17_653 VGND VGND VPWR VPWR sky130_fd_sc_hd__decap_3
XFILLER_32_601 VGND VGND VPWR VPWR sky130_fd_sc_hd__decap_3
XFILLER_44_472 VGND VGND VPWR VPWR sky130_fd_sc_hd__decap_3
Xplace269 _4907_/Y VGND VGND VPWR VPWR _5657_/B sky130_fd_sc_hd__buf_2
XFILLER_17_697 VGND VGND VPWR VPWR sky130_fd_sc_hd__decap_3
XFILLER_44_483 VGND VGND VPWR VPWR sky130_fd_sc_hd__fill_2
XFILLER_32_634 VGND VGND VPWR VPWR sky130_fd_sc_hd__decap_3
XFILLER_32_645 VGND VGND VPWR VPWR sky130_fd_sc_hd__decap_3
XFILLER_31_133 VGND VGND VPWR VPWR sky130_fd_sc_hd__fill_2
XFILLER_32_678 VGND VGND VPWR VPWR sky130_fd_sc_hd__decap_3
X_3790_ _3746_/X _3777_/X _3779_/X _3923_/A1 _3789_/X VGND VGND VPWR VPWR _3790_/X
+ sky130_fd_sc_hd__a221o_2
XFILLER_31_166 VGND VGND VPWR VPWR sky130_fd_sc_hd__fill_2
XFILLER_31_199 VGND VGND VPWR VPWR sky130_fd_sc_hd__decap_3
XFILLER_118_728 VGND VGND VPWR VPWR sky130_fd_sc_hd__decap_3
XFILLER_8_373 VGND VGND VPWR VPWR sky130_fd_sc_hd__decap_3
X_4411_ _4411_/A _4411_/B VGND VGND VPWR VPWR _4412_/B sky130_fd_sc_hd__and2_2
XFILLER_99_612 VGND VGND VPWR VPWR sky130_fd_sc_hd__decap_3
XFILLER_99_623 VGND VGND VPWR VPWR sky130_fd_sc_hd__decap_3
X_7130_ _7325_/CLK _7130_/D _6410_/Y VGND VGND VPWR VPWR _7130_/Q sky130_fd_sc_hd__dfrtp_2
XTAP_TAPCELL_ROW_74_1233 VGND VPWR sky130_fd_sc_hd__tapvpwrvgnd_1
X_4342_ _7063_/Q _4305_/B _4460_/A VGND VGND VPWR VPWR _4365_/B sky130_fd_sc_hd__o21a_2
XFILLER_99_656 VGND VGND VPWR VPWR sky130_fd_sc_hd__decap_3
XFILLER_113_433 VGND VGND VPWR VPWR sky130_fd_sc_hd__decap_3
XFILLER_113_444 VGND VGND VPWR VPWR sky130_fd_sc_hd__decap_3
X_7061_ _7279_/CLK _7061_/D _6341_/Y VGND VGND VPWR VPWR _7061_/Q sky130_fd_sc_hd__dfrtp_2
X_4273_ _4376_/A _4376_/B _4376_/C _4273_/D VGND VGND VPWR VPWR _4273_/Y sky130_fd_sc_hd__nor4_1
XFILLER_101_606 VGND VGND VPWR VPWR sky130_fd_sc_hd__decap_3
XFILLER_98_166 VGND VGND VPWR VPWR sky130_fd_sc_hd__decap_3
XFILLER_101_617 VGND VGND VPWR VPWR sky130_fd_sc_hd__decap_3
XFILLER_98_188 VGND VGND VPWR VPWR sky130_fd_sc_hd__decap_3
XFILLER_86_328 VGND VGND VPWR VPWR sky130_fd_sc_hd__decap_3
.ends
