* NGSPICE file created from single_cycle_cpu.ext - technology: sky130A

* Black-box entry subcircuit for sky130_fd_sc_hd__decap_3 abstract view
.subckt sky130_fd_sc_hd__decap_3 VGND VNB VPB VPWR
.ends

* Black-box entry subcircuit for sky130_fd_sc_hd__fill_2 abstract view
.subckt sky130_fd_sc_hd__fill_2 VGND VNB VPB VPWR
.ends

* Black-box entry subcircuit for sky130_fd_sc_hd__tapvpwrvgnd_1 abstract view
.subckt sky130_fd_sc_hd__tapvpwrvgnd_1 VGND VPWR
.ends

* Black-box entry subcircuit for sky130_fd_sc_hd__dfxtp_2 abstract view
.subckt sky130_fd_sc_hd__dfxtp_2 CLK D VGND VNB VPB VPWR Q
.ends

* Black-box entry subcircuit for sky130_fd_sc_hd__fill_1 abstract view
.subckt sky130_fd_sc_hd__fill_1 VGND VNB VPB VPWR
.ends

* Black-box entry subcircuit for sky130_fd_sc_hd__mux2_2 abstract view
.subckt sky130_fd_sc_hd__mux2_2 A0 A1 S VGND VNB VPB VPWR X
.ends

* Black-box entry subcircuit for sky130_fd_sc_hd__nor4_2 abstract view
.subckt sky130_fd_sc_hd__nor4_2 A B C D VGND VNB VPB VPWR Y
.ends

* Black-box entry subcircuit for sky130_fd_sc_hd__or2_2 abstract view
.subckt sky130_fd_sc_hd__or2_2 A B VGND VNB VPB VPWR X
.ends

* Black-box entry subcircuit for sky130_fd_sc_hd__dfrtp_2 abstract view
.subckt sky130_fd_sc_hd__dfrtp_2 CLK D RESET_B VGND VNB VPB VPWR Q
.ends

* Black-box entry subcircuit for sky130_fd_sc_hd__dlygate4sd3_1 abstract view
.subckt sky130_fd_sc_hd__dlygate4sd3_1 A VGND VNB VPB VPWR X
.ends

* Black-box entry subcircuit for sky130_fd_sc_hd__nor3_2 abstract view
.subckt sky130_fd_sc_hd__nor3_2 A B C VGND VNB VPB VPWR Y
.ends

* Black-box entry subcircuit for sky130_fd_sc_hd__a221o_2 abstract view
.subckt sky130_fd_sc_hd__a221o_2 A1 A2 B1 B2 C1 VGND VNB VPB VPWR X
.ends

* Black-box entry subcircuit for sky130_fd_sc_hd__inv_2 abstract view
.subckt sky130_fd_sc_hd__inv_2 A VGND VNB VPB VPWR Y
.ends

* Black-box entry subcircuit for sky130_fd_sc_hd__a22o_2 abstract view
.subckt sky130_fd_sc_hd__a22o_2 A1 A2 B1 B2 VGND VNB VPB VPWR X
.ends

* Black-box entry subcircuit for sky130_fd_sc_hd__clkdlybuf4s25_1 abstract view
.subckt sky130_fd_sc_hd__clkdlybuf4s25_1 A VGND VNB VPB VPWR X
.ends

* Black-box entry subcircuit for sky130_fd_sc_hd__a211o_2 abstract view
.subckt sky130_fd_sc_hd__a211o_2 A1 A2 B1 C1 VGND VNB VPB VPWR X
.ends

* Black-box entry subcircuit for sky130_fd_sc_hd__and3_4 abstract view
.subckt sky130_fd_sc_hd__and3_4 A B C VGND VNB VPB VPWR X
.ends

* Black-box entry subcircuit for sky130_fd_sc_hd__a31o_2 abstract view
.subckt sky130_fd_sc_hd__a31o_2 A1 A2 A3 B1 VGND VNB VPB VPWR X
.ends

* Black-box entry subcircuit for sky130_fd_sc_hd__or4_4 abstract view
.subckt sky130_fd_sc_hd__or4_4 A B C D VGND VNB VPB VPWR X
.ends

* Black-box entry subcircuit for sky130_fd_sc_hd__nor2_2 abstract view
.subckt sky130_fd_sc_hd__nor2_2 A B VGND VNB VPB VPWR Y
.ends

* Black-box entry subcircuit for sky130_fd_sc_hd__o31a_2 abstract view
.subckt sky130_fd_sc_hd__o31a_2 A1 A2 A3 B1 VGND VNB VPB VPWR X
.ends

* Black-box entry subcircuit for sky130_fd_sc_hd__or3b_4 abstract view
.subckt sky130_fd_sc_hd__or3b_4 A B C_N VGND VNB VPB VPWR X
.ends

* Black-box entry subcircuit for sky130_fd_sc_hd__and2_2 abstract view
.subckt sky130_fd_sc_hd__and2_2 A B VGND VNB VPB VPWR X
.ends

* Black-box entry subcircuit for sky130_fd_sc_hd__xnor2_2 abstract view
.subckt sky130_fd_sc_hd__xnor2_2 A B VGND VNB VPB VPWR Y
.ends

* Black-box entry subcircuit for sky130_fd_sc_hd__o21ai_2 abstract view
.subckt sky130_fd_sc_hd__o21ai_2 A1 A2 B1 VGND VNB VPB VPWR Y
.ends

* Black-box entry subcircuit for sky130_fd_sc_hd__nand2_2 abstract view
.subckt sky130_fd_sc_hd__nand2_2 A B VGND VNB VPB VPWR Y
.ends

* Black-box entry subcircuit for sky130_fd_sc_hd__and3_2 abstract view
.subckt sky130_fd_sc_hd__and3_2 A B C VGND VNB VPB VPWR X
.ends

* Black-box entry subcircuit for sky130_fd_sc_hd__and2b_2 abstract view
.subckt sky130_fd_sc_hd__and2b_2 A_N B VGND VNB VPB VPWR X
.ends

* Black-box entry subcircuit for sky130_fd_sc_hd__a21o_2 abstract view
.subckt sky130_fd_sc_hd__a21o_2 A1 A2 B1 VGND VNB VPB VPWR X
.ends

* Black-box entry subcircuit for sky130_fd_sc_hd__or3_2 abstract view
.subckt sky130_fd_sc_hd__or3_2 A B C VGND VNB VPB VPWR X
.ends

* Black-box entry subcircuit for sky130_fd_sc_hd__buf_2 abstract view
.subckt sky130_fd_sc_hd__buf_2 A VGND VNB VPB VPWR X
.ends

* Black-box entry subcircuit for sky130_fd_sc_hd__diode_2 abstract view
.subckt sky130_fd_sc_hd__diode_2 DIODE VGND VNB VPB VPWR
.ends

* Black-box entry subcircuit for sky130_fd_sc_hd__a31oi_4 abstract view
.subckt sky130_fd_sc_hd__a31oi_4 A1 A2 A3 B1 VGND VNB VPB VPWR Y
.ends

* Black-box entry subcircuit for sky130_fd_sc_hd__o21a_2 abstract view
.subckt sky130_fd_sc_hd__o21a_2 A1 A2 B1 VGND VNB VPB VPWR X
.ends

* Black-box entry subcircuit for sky130_fd_sc_hd__o32a_2 abstract view
.subckt sky130_fd_sc_hd__o32a_2 A1 A2 A3 B1 B2 VGND VNB VPB VPWR X
.ends

* Black-box entry subcircuit for sky130_fd_sc_hd__or3b_2 abstract view
.subckt sky130_fd_sc_hd__or3b_2 A B C_N VGND VNB VPB VPWR X
.ends

* Black-box entry subcircuit for sky130_fd_sc_hd__clkbuf_16 abstract view
.subckt sky130_fd_sc_hd__clkbuf_16 A VGND VNB VPB VPWR X
.ends

* Black-box entry subcircuit for sky130_fd_sc_hd__o211ai_2 abstract view
.subckt sky130_fd_sc_hd__o211ai_2 A1 A2 B1 C1 VGND VNB VPB VPWR Y
.ends

* Black-box entry subcircuit for sky130_fd_sc_hd__o22a_2 abstract view
.subckt sky130_fd_sc_hd__o22a_2 A1 A2 B1 B2 VGND VNB VPB VPWR X
.ends

* Black-box entry subcircuit for sky130_fd_sc_hd__o221a_2 abstract view
.subckt sky130_fd_sc_hd__o221a_2 A1 A2 B1 B2 C1 VGND VNB VPB VPWR X
.ends

* Black-box entry subcircuit for sky130_fd_sc_hd__o311a_4 abstract view
.subckt sky130_fd_sc_hd__o311a_4 A1 A2 A3 B1 C1 VGND VNB VPB VPWR X
.ends

* Black-box entry subcircuit for sky130_fd_sc_hd__a211oi_4 abstract view
.subckt sky130_fd_sc_hd__a211oi_4 A1 A2 B1 C1 VGND VNB VPB VPWR Y
.ends

* Black-box entry subcircuit for sky130_fd_sc_hd__xor2_2 abstract view
.subckt sky130_fd_sc_hd__xor2_2 A B VGND VNB VPB VPWR X
.ends

* Black-box entry subcircuit for sky130_fd_sc_hd__or4b_2 abstract view
.subckt sky130_fd_sc_hd__or4b_2 A B C D_N VGND VNB VPB VPWR X
.ends

* Black-box entry subcircuit for sky130_fd_sc_hd__o2bb2a_2 abstract view
.subckt sky130_fd_sc_hd__o2bb2a_2 A1_N A2_N B1 B2 VGND VNB VPB VPWR X
.ends

* Black-box entry subcircuit for sky130_fd_sc_hd__nand3_2 abstract view
.subckt sky130_fd_sc_hd__nand3_2 A B C VGND VNB VPB VPWR Y
.ends

* Black-box entry subcircuit for sky130_fd_sc_hd__o31ai_4 abstract view
.subckt sky130_fd_sc_hd__o31ai_4 A1 A2 A3 B1 VGND VNB VPB VPWR Y
.ends

* Black-box entry subcircuit for sky130_fd_sc_hd__o21ba_2 abstract view
.subckt sky130_fd_sc_hd__o21ba_2 A1 A2 B1_N VGND VNB VPB VPWR X
.ends

* Black-box entry subcircuit for sky130_fd_sc_hd__or2_4 abstract view
.subckt sky130_fd_sc_hd__or2_4 A B VGND VNB VPB VPWR X
.ends

* Black-box entry subcircuit for sky130_fd_sc_hd__a211oi_2 abstract view
.subckt sky130_fd_sc_hd__a211oi_2 A1 A2 B1 C1 VGND VNB VPB VPWR Y
.ends

* Black-box entry subcircuit for sky130_fd_sc_hd__a21bo_2 abstract view
.subckt sky130_fd_sc_hd__a21bo_2 A1 A2 B1_N VGND VNB VPB VPWR X
.ends

* Black-box entry subcircuit for sky130_fd_sc_hd__a31oi_2 abstract view
.subckt sky130_fd_sc_hd__a31oi_2 A1 A2 A3 B1 VGND VNB VPB VPWR Y
.ends

* Black-box entry subcircuit for sky130_fd_sc_hd__a21oi_2 abstract view
.subckt sky130_fd_sc_hd__a21oi_2 A1 A2 B1 VGND VNB VPB VPWR Y
.ends

* Black-box entry subcircuit for sky130_fd_sc_hd__o211a_2 abstract view
.subckt sky130_fd_sc_hd__o211a_2 A1 A2 B1 C1 VGND VNB VPB VPWR X
.ends

* Black-box entry subcircuit for sky130_fd_sc_hd__or2b_2 abstract view
.subckt sky130_fd_sc_hd__or2b_2 A B_N VGND VNB VPB VPWR X
.ends

* Black-box entry subcircuit for sky130_fd_sc_hd__a32o_2 abstract view
.subckt sky130_fd_sc_hd__a32o_2 A1 A2 A3 B1 B2 VGND VNB VPB VPWR X
.ends

* Black-box entry subcircuit for sky130_fd_sc_hd__a2bb2o_2 abstract view
.subckt sky130_fd_sc_hd__a2bb2o_2 A1_N A2_N B1 B2 VGND VNB VPB VPWR X
.ends

* Black-box entry subcircuit for sky130_fd_sc_hd__xor2_4 abstract view
.subckt sky130_fd_sc_hd__xor2_4 A B VGND VNB VPB VPWR X
.ends

* Black-box entry subcircuit for sky130_fd_sc_hd__a21boi_2 abstract view
.subckt sky130_fd_sc_hd__a21boi_2 A1 A2 B1_N VGND VNB VPB VPWR Y
.ends

* Black-box entry subcircuit for sky130_fd_sc_hd__and2_4 abstract view
.subckt sky130_fd_sc_hd__and2_4 A B VGND VNB VPB VPWR X
.ends

* Black-box entry subcircuit for sky130_fd_sc_hd__o2111a_2 abstract view
.subckt sky130_fd_sc_hd__o2111a_2 A1 A2 B1 C1 D1 VGND VNB VPB VPWR X
.ends

* Black-box entry subcircuit for sky130_fd_sc_hd__and4_4 abstract view
.subckt sky130_fd_sc_hd__and4_4 A B C D VGND VNB VPB VPWR X
.ends

* Black-box entry subcircuit for sky130_fd_sc_hd__o31ai_1 abstract view
.subckt sky130_fd_sc_hd__o31ai_1 A1 A2 A3 B1 VGND VNB VPB VPWR Y
.ends

* Black-box entry subcircuit for sky130_fd_sc_hd__buf_1 abstract view
.subckt sky130_fd_sc_hd__buf_1 A VGND VNB VPB VPWR X
.ends

* Black-box entry subcircuit for sky130_fd_sc_hd__o311a_2 abstract view
.subckt sky130_fd_sc_hd__o311a_2 A1 A2 A3 B1 C1 VGND VNB VPB VPWR X
.ends

* Black-box entry subcircuit for sky130_fd_sc_hd__o31ai_2 abstract view
.subckt sky130_fd_sc_hd__o31ai_2 A1 A2 A3 B1 VGND VNB VPB VPWR Y
.ends

* Black-box entry subcircuit for sky130_fd_sc_hd__clkinv_2 abstract view
.subckt sky130_fd_sc_hd__clkinv_2 A VGND VNB VPB VPWR Y
.ends

* Black-box entry subcircuit for sky130_fd_sc_hd__a31o_4 abstract view
.subckt sky130_fd_sc_hd__a31o_4 A1 A2 A3 B1 VGND VNB VPB VPWR X
.ends

* Black-box entry subcircuit for sky130_fd_sc_hd__clkbuf_1 abstract view
.subckt sky130_fd_sc_hd__clkbuf_1 A VGND VNB VPB VPWR X
.ends

* Black-box entry subcircuit for sky130_fd_sc_hd__clkbuf_8 abstract view
.subckt sky130_fd_sc_hd__clkbuf_8 A VGND VNB VPB VPWR X
.ends

* Black-box entry subcircuit for sky130_fd_sc_hd__inv_4 abstract view
.subckt sky130_fd_sc_hd__inv_4 A VGND VNB VPB VPWR Y
.ends

* Black-box entry subcircuit for sky130_fd_sc_hd__nor2_4 abstract view
.subckt sky130_fd_sc_hd__nor2_4 A B VGND VNB VPB VPWR Y
.ends

* Black-box entry subcircuit for sky130_fd_sc_hd__a221oi_2 abstract view
.subckt sky130_fd_sc_hd__a221oi_2 A1 A2 B1 B2 C1 VGND VNB VPB VPWR Y
.ends

* Black-box entry subcircuit for sky130_fd_sc_hd__and3b_2 abstract view
.subckt sky130_fd_sc_hd__and3b_2 A_N B C VGND VNB VPB VPWR X
.ends

* Black-box entry subcircuit for sky130_fd_sc_hd__nand3b_2 abstract view
.subckt sky130_fd_sc_hd__nand3b_2 A_N B C VGND VNB VPB VPWR Y
.ends

* Black-box entry subcircuit for sky130_fd_sc_hd__inv_6 abstract view
.subckt sky130_fd_sc_hd__inv_6 A VGND VNB VPB VPWR Y
.ends

* Black-box entry subcircuit for sky130_fd_sc_hd__or3_4 abstract view
.subckt sky130_fd_sc_hd__or3_4 A B C VGND VNB VPB VPWR X
.ends

* Black-box entry subcircuit for sky130_fd_sc_hd__nor4b_2 abstract view
.subckt sky130_fd_sc_hd__nor4b_2 A B C D_N VGND VNB VPB VPWR Y
.ends

* Black-box entry subcircuit for sky130_fd_sc_hd__a21oi_4 abstract view
.subckt sky130_fd_sc_hd__a21oi_4 A1 A2 B1 VGND VNB VPB VPWR Y
.ends

* Black-box entry subcircuit for sky130_fd_sc_hd__o221ai_2 abstract view
.subckt sky130_fd_sc_hd__o221ai_2 A1 A2 B1 B2 C1 VGND VNB VPB VPWR Y
.ends

* Black-box entry subcircuit for sky130_fd_sc_hd__nand2b_4 abstract view
.subckt sky130_fd_sc_hd__nand2b_4 A_N B VGND VNB VPB VPWR Y
.ends

* Black-box entry subcircuit for sky130_fd_sc_hd__clkbuf_2 abstract view
.subckt sky130_fd_sc_hd__clkbuf_2 A VGND VNB VPB VPWR X
.ends

* Black-box entry subcircuit for sky130_fd_sc_hd__a2111o_2 abstract view
.subckt sky130_fd_sc_hd__a2111o_2 A1 A2 B1 C1 D1 VGND VNB VPB VPWR X
.ends

* Black-box entry subcircuit for sky130_fd_sc_hd__mux4_2 abstract view
.subckt sky130_fd_sc_hd__mux4_2 A0 A1 A2 A3 S0 S1 VGND VNB VPB VPWR X
.ends

* Black-box entry subcircuit for sky130_fd_sc_hd__dfstp_2 abstract view
.subckt sky130_fd_sc_hd__dfstp_2 CLK D SET_B VGND VNB VPB VPWR Q
.ends

* Black-box entry subcircuit for sky130_fd_sc_hd__nor2b_2 abstract view
.subckt sky130_fd_sc_hd__nor2b_2 A B_N VGND VNB VPB VPWR Y
.ends

* Black-box entry subcircuit for sky130_fd_sc_hd__or4_2 abstract view
.subckt sky130_fd_sc_hd__or4_2 A B C D VGND VNB VPB VPWR X
.ends

* Black-box entry subcircuit for sky130_fd_sc_hd__buf_4 abstract view
.subckt sky130_fd_sc_hd__buf_4 A VGND VNB VPB VPWR X
.ends

* Black-box entry subcircuit for sky130_fd_sc_hd__bufinv_16 abstract view
.subckt sky130_fd_sc_hd__bufinv_16 A VGND VNB VPB VPWR Y
.ends

* Black-box entry subcircuit for sky130_fd_sc_hd__and4_2 abstract view
.subckt sky130_fd_sc_hd__and4_2 A B C D VGND VNB VPB VPWR X
.ends

* Black-box entry subcircuit for sky130_fd_sc_hd__inv_8 abstract view
.subckt sky130_fd_sc_hd__inv_8 A VGND VNB VPB VPWR Y
.ends

* Black-box entry subcircuit for sky130_fd_sc_hd__clkinv_4 abstract view
.subckt sky130_fd_sc_hd__clkinv_4 A VGND VNB VPB VPWR Y
.ends

* Black-box entry subcircuit for sky130_fd_sc_hd__a311oi_2 abstract view
.subckt sky130_fd_sc_hd__a311oi_2 A1 A2 A3 B1 C1 VGND VNB VPB VPWR Y
.ends

* Black-box entry subcircuit for sky130_fd_sc_hd__o21a_4 abstract view
.subckt sky130_fd_sc_hd__o21a_4 A1 A2 B1 VGND VNB VPB VPWR X
.ends

* Black-box entry subcircuit for sky130_fd_sc_hd__a41o_2 abstract view
.subckt sky130_fd_sc_hd__a41o_2 A1 A2 A3 A4 B1 VGND VNB VPB VPWR X
.ends

* Black-box entry subcircuit for sky130_fd_sc_hd__nand4bb_2 abstract view
.subckt sky130_fd_sc_hd__nand4bb_2 A_N B_N C D VGND VNB VPB VPWR Y
.ends

* Black-box entry subcircuit for sky130_fd_sc_hd__o21bai_2 abstract view
.subckt sky130_fd_sc_hd__o21bai_2 A1 A2 B1_N VGND VNB VPB VPWR Y
.ends

* Black-box entry subcircuit for sky130_fd_sc_hd__nand2_4 abstract view
.subckt sky130_fd_sc_hd__nand2_4 A B VGND VNB VPB VPWR Y
.ends

* Black-box entry subcircuit for sky130_fd_sc_hd__mux2_4 abstract view
.subckt sky130_fd_sc_hd__mux2_4 A0 A1 S VGND VNB VPB VPWR X
.ends

* Black-box entry subcircuit for sky130_fd_sc_hd__o211ai_4 abstract view
.subckt sky130_fd_sc_hd__o211ai_4 A1 A2 B1 C1 VGND VNB VPB VPWR Y
.ends

* Black-box entry subcircuit for sky130_fd_sc_hd__and4bb_4 abstract view
.subckt sky130_fd_sc_hd__and4bb_4 A_N B_N C D VGND VNB VPB VPWR X
.ends

* Black-box entry subcircuit for sky130_fd_sc_hd__nand2b_2 abstract view
.subckt sky130_fd_sc_hd__nand2b_2 A_N B VGND VNB VPB VPWR Y
.ends

* Black-box entry subcircuit for sky130_fd_sc_hd__o211a_4 abstract view
.subckt sky130_fd_sc_hd__o211a_4 A1 A2 B1 C1 VGND VNB VPB VPWR X
.ends

* Black-box entry subcircuit for sky130_fd_sc_hd__or4b_4 abstract view
.subckt sky130_fd_sc_hd__or4b_4 A B C D_N VGND VNB VPB VPWR X
.ends

* Black-box entry subcircuit for sky130_fd_sc_hd__nor4bb_1 abstract view
.subckt sky130_fd_sc_hd__nor4bb_1 A B C_N D_N VGND VNB VPB VPWR Y
.ends

* Black-box entry subcircuit for sky130_fd_sc_hd__and4b_4 abstract view
.subckt sky130_fd_sc_hd__and4b_4 A_N B C D VGND VNB VPB VPWR X
.ends

* Black-box entry subcircuit for sky130_fd_sc_hd__nor3b_2 abstract view
.subckt sky130_fd_sc_hd__nor3b_2 A B C_N VGND VNB VPB VPWR Y
.ends

* Black-box entry subcircuit for sky130_fd_sc_hd__a22oi_2 abstract view
.subckt sky130_fd_sc_hd__a22oi_2 A1 A2 B1 B2 VGND VNB VPB VPWR Y
.ends

* Black-box entry subcircuit for sky130_fd_sc_hd__a311o_2 abstract view
.subckt sky130_fd_sc_hd__a311o_2 A1 A2 A3 B1 C1 VGND VNB VPB VPWR X
.ends

* Black-box entry subcircuit for sky130_fd_sc_hd__conb_1 abstract view
.subckt sky130_fd_sc_hd__conb_1 VGND VNB VPB VPWR HI LO
.ends

* Black-box entry subcircuit for sky130_fd_sc_hd__nand4b_4 abstract view
.subckt sky130_fd_sc_hd__nand4b_4 A_N B C D VGND VNB VPB VPWR Y
.ends

* Black-box entry subcircuit for sky130_fd_sc_hd__a2bb2o_4 abstract view
.subckt sky130_fd_sc_hd__a2bb2o_4 A1_N A2_N B1 B2 VGND VNB VPB VPWR X
.ends

* Black-box entry subcircuit for sky130_fd_sc_hd__nor4_1 abstract view
.subckt sky130_fd_sc_hd__nor4_1 A B C D VGND VNB VPB VPWR Y
.ends

.subckt single_cycle_cpu VGND VPWR alu_result_out[0] alu_result_out[10] alu_result_out[11]
+ alu_result_out[12] alu_result_out[13] alu_result_out[14] alu_result_out[15] alu_result_out[16]
+ alu_result_out[17] alu_result_out[18] alu_result_out[19] alu_result_out[1] alu_result_out[20]
+ alu_result_out[21] alu_result_out[22] alu_result_out[23] alu_result_out[24] alu_result_out[25]
+ alu_result_out[26] alu_result_out[27] alu_result_out[28] alu_result_out[29] alu_result_out[2]
+ alu_result_out[30] alu_result_out[31] alu_result_out[3] alu_result_out[4] alu_result_out[5]
+ alu_result_out[6] alu_result_out[7] alu_result_out[8] alu_result_out[9] clk instruction_out[0]
+ instruction_out[10] instruction_out[11] instruction_out[12] instruction_out[13]
+ instruction_out[14] instruction_out[15] instruction_out[16] instruction_out[17]
+ instruction_out[18] instruction_out[19] instruction_out[1] instruction_out[20] instruction_out[21]
+ instruction_out[22] instruction_out[23] instruction_out[24] instruction_out[25]
+ instruction_out[26] instruction_out[27] instruction_out[28] instruction_out[29]
+ instruction_out[2] instruction_out[30] instruction_out[31] instruction_out[3] instruction_out[4]
+ instruction_out[5] instruction_out[6] instruction_out[7] instruction_out[8] instruction_out[9]
+ pc_out[0] pc_out[10] pc_out[11] pc_out[12] pc_out[13] pc_out[14] pc_out[15] pc_out[16]
+ pc_out[17] pc_out[18] pc_out[19] pc_out[1] pc_out[20] pc_out[21] pc_out[22] pc_out[23]
+ pc_out[24] pc_out[25] pc_out[26] pc_out[27] pc_out[28] pc_out[29] pc_out[2] pc_out[30]
+ pc_out[31] pc_out[3] pc_out[4] pc_out[5] pc_out[6] pc_out[7] pc_out[8] pc_out[9]
+ reset
XFILLER_39_211 VGND VGND VPWR VPWR sky130_fd_sc_hd__decap_3
XFILLER_67_542 VGND VGND VPWR VPWR sky130_fd_sc_hd__fill_2
XFILLER_67_564 VGND VGND VPWR VPWR sky130_fd_sc_hd__decap_3
XFILLER_54_236 VGND VGND VPWR VPWR sky130_fd_sc_hd__decap_3
XFILLER_67_597 VGND VGND VPWR VPWR sky130_fd_sc_hd__decap_3
XFILLER_94_383 VGND VGND VPWR VPWR sky130_fd_sc_hd__fill_2
XTAP_TAPCELL_ROW_68_1015 VGND VPWR sky130_fd_sc_hd__tapvpwrvgnd_1
X_6914_ _6963_/CLK _6914_/D VGND VGND VPWR VPWR _6914_/Q sky130_fd_sc_hd__dfxtp_2
XFILLER_22_100 VGND VGND VPWR VPWR sky130_fd_sc_hd__decap_3
XFILLER_23_601 VGND VGND VPWR VPWR sky130_fd_sc_hd__decap_3
XFILLER_23_623 VGND VGND VPWR VPWR sky130_fd_sc_hd__decap_3
XFILLER_35_472 VGND VGND VPWR VPWR sky130_fd_sc_hd__fill_1
XFILLER_22_122 VGND VGND VPWR VPWR sky130_fd_sc_hd__decap_3
XFILLER_35_494 VGND VGND VPWR VPWR sky130_fd_sc_hd__fill_2
XFILLER_52_29 VGND VGND VPWR VPWR sky130_fd_sc_hd__decap_3
X_6845_ clkload5/A _6845_/D VGND VGND VPWR VPWR _6845_/Q sky130_fd_sc_hd__dfxtp_2
XFILLER_50_464 VGND VGND VPWR VPWR sky130_fd_sc_hd__decap_3
X_6776_ _6966_/CLK _6776_/D VGND VGND VPWR VPWR _6776_/Q sky130_fd_sc_hd__dfxtp_2
XFILLER_22_177 VGND VGND VPWR VPWR sky130_fd_sc_hd__decap_3
XFILLER_50_486 VGND VGND VPWR VPWR sky130_fd_sc_hd__decap_3
X_5727_ _7369_/Q hold912/X _5737_/S VGND VGND VPWR VPWR _6713_/D sky130_fd_sc_hd__mux2_2
X_5658_ _5658_/A _5658_/B _5658_/C _5658_/D VGND VGND VPWR VPWR _5661_/C sky130_fd_sc_hd__nor4_2
XTAP_TAPCELL_ROW_79_1144 VGND VPWR sky130_fd_sc_hd__tapvpwrvgnd_1
X_5589_ _5589_/A _5595_/B VGND VGND VPWR VPWR _7033_/D sky130_fd_sc_hd__or2_2
XFILLER_104_411 VGND VGND VPWR VPWR sky130_fd_sc_hd__decap_3
X_7328_ _7364_/CLK _7328_/D _6608_/Y VGND VGND VPWR VPWR _7328_/Q sky130_fd_sc_hd__dfrtp_2
XFILLER_104_433 VGND VGND VPWR VPWR sky130_fd_sc_hd__fill_1
XFILLER_89_144 VGND VGND VPWR VPWR sky130_fd_sc_hd__decap_3
X_7259_ _7357_/CLK _7259_/D _6539_/Y VGND VGND VPWR VPWR _7259_/Q sky130_fd_sc_hd__dfrtp_2
XFILLER_104_488 VGND VGND VPWR VPWR sky130_fd_sc_hd__decap_3
XFILLER_77_328 VGND VGND VPWR VPWR sky130_fd_sc_hd__decap_3
XFILLER_89_166 VGND VGND VPWR VPWR sky130_fd_sc_hd__fill_2
XFILLER_58_575 VGND VGND VPWR VPWR sky130_fd_sc_hd__decap_3
XFILLER_85_350 VGND VGND VPWR VPWR sky130_fd_sc_hd__fill_1
XFILLER_85_361 VGND VGND VPWR VPWR sky130_fd_sc_hd__decap_3
XFILLER_92_309 VGND VGND VPWR VPWR sky130_fd_sc_hd__decap_3
Xhold1040 _7404_/Q VGND VGND VPWR VPWR _3684_/A1 sky130_fd_sc_hd__dlygate4sd3_1
Xhold1051 _7216_/Q VGND VGND VPWR VPWR _5225_/A sky130_fd_sc_hd__dlygate4sd3_1
XFILLER_45_203 VGND VGND VPWR VPWR sky130_fd_sc_hd__decap_3
XFILLER_45_225 VGND VGND VPWR VPWR sky130_fd_sc_hd__decap_3
XFILLER_73_545 VGND VGND VPWR VPWR sky130_fd_sc_hd__decap_3
Xhold1062 _7263_/Q VGND VGND VPWR VPWR _4979_/A0 sky130_fd_sc_hd__dlygate4sd3_1
Xhold1073 _7229_/Q VGND VGND VPWR VPWR _5198_/A sky130_fd_sc_hd__dlygate4sd3_1
Xhold1084 _7397_/Q VGND VGND VPWR VPWR _3754_/A1 sky130_fd_sc_hd__dlygate4sd3_1
Xhold1095 _7402_/Q VGND VGND VPWR VPWR _3698_/A1 sky130_fd_sc_hd__dlygate4sd3_1
XFILLER_14_601 VGND VGND VPWR VPWR sky130_fd_sc_hd__decap_3
XFILLER_26_472 VGND VGND VPWR VPWR sky130_fd_sc_hd__decap_3
XFILLER_60_228 VGND VGND VPWR VPWR sky130_fd_sc_hd__decap_3
XFILLER_73_589 VGND VGND VPWR VPWR sky130_fd_sc_hd__decap_3
XFILLER_14_634 VGND VGND VPWR VPWR sky130_fd_sc_hd__decap_3
XFILLER_14_645 VGND VGND VPWR VPWR sky130_fd_sc_hd__decap_3
XFILLER_13_188 VGND VGND VPWR VPWR sky130_fd_sc_hd__decap_3
XFILLER_42_73 VGND VGND VPWR VPWR sky130_fd_sc_hd__fill_2
XTAP_TAPCELL_ROW_11_356 VGND VPWR sky130_fd_sc_hd__tapvpwrvgnd_1
XFILLER_5_321 VGND VGND VPWR VPWR sky130_fd_sc_hd__decap_3
XFILLER_5_343 VGND VGND VPWR VPWR sky130_fd_sc_hd__fill_2
XFILLER_3_12 VGND VGND VPWR VPWR sky130_fd_sc_hd__decap_3
XFILLER_68_306 VGND VGND VPWR VPWR sky130_fd_sc_hd__fill_2
XFILLER_1_582 VGND VGND VPWR VPWR sky130_fd_sc_hd__decap_3
XFILLER_1_593 VGND VGND VPWR VPWR sky130_fd_sc_hd__decap_3
XFILLER_95_136 VGND VGND VPWR VPWR sky130_fd_sc_hd__decap_3
XFILLER_76_361 VGND VGND VPWR VPWR sky130_fd_sc_hd__decap_3
XFILLER_83_309 VGND VGND VPWR VPWR sky130_fd_sc_hd__fill_2
XFILLER_95_169 VGND VGND VPWR VPWR sky130_fd_sc_hd__decap_3
XFILLER_36_203 VGND VGND VPWR VPWR sky130_fd_sc_hd__decap_3
XFILLER_76_383 VGND VGND VPWR VPWR sky130_fd_sc_hd__decap_3
XFILLER_24_409 VGND VGND VPWR VPWR sky130_fd_sc_hd__decap_3
XFILLER_36_247 VGND VGND VPWR VPWR sky130_fd_sc_hd__decap_3
XFILLER_64_556 VGND VGND VPWR VPWR sky130_fd_sc_hd__decap_3
XFILLER_64_578 VGND VGND VPWR VPWR sky130_fd_sc_hd__fill_1
XFILLER_91_353 VGND VGND VPWR VPWR sky130_fd_sc_hd__decap_3
XTAP_TAPCELL_ROW_19_456 VGND VPWR sky130_fd_sc_hd__tapvpwrvgnd_1
XFILLER_51_206 VGND VGND VPWR VPWR sky130_fd_sc_hd__decap_3
XFILLER_51_217 VGND VGND VPWR VPWR sky130_fd_sc_hd__decap_3
XFILLER_51_228 VGND VGND VPWR VPWR sky130_fd_sc_hd__decap_3
XFILLER_64_589 VGND VGND VPWR VPWR sky130_fd_sc_hd__fill_1
XFILLER_91_386 VGND VGND VPWR VPWR sky130_fd_sc_hd__decap_3
X_4960_ _5647_/A _4960_/B _4960_/C VGND VGND VPWR VPWR _4961_/C sky130_fd_sc_hd__nor3_2
XTAP_TAPCELL_ROW_47_776 VGND VPWR sky130_fd_sc_hd__tapvpwrvgnd_1
XFILLER_44_291 VGND VGND VPWR VPWR sky130_fd_sc_hd__decap_3
X_4891_ _5006_/A1 _4126_/A _4889_/Y _4811_/C _4890_/Y VGND VGND VPWR VPWR _4891_/X
+ sky130_fd_sc_hd__a221o_2
X_3911_ _6690_/Q _3911_/A2 _3911_/B1 _6868_/Q _3910_/X VGND VGND VPWR VPWR _3911_/X
+ sky130_fd_sc_hd__a221o_2
XFILLER_20_604 VGND VGND VPWR VPWR sky130_fd_sc_hd__decap_3
XFILLER_32_464 VGND VGND VPWR VPWR sky130_fd_sc_hd__fill_1
X_6630_ _6630_/A VGND VGND VPWR VPWR _6630_/Y sky130_fd_sc_hd__inv_2
X_3842_ _6925_/Q _3886_/A2 _3886_/B1 _6789_/Q VGND VGND VPWR VPWR _3842_/X sky130_fd_sc_hd__a22o_2
XFILLER_20_637 VGND VGND VPWR VPWR sky130_fd_sc_hd__decap_3
X_6561_ _6635_/A VGND VGND VPWR VPWR _6561_/Y sky130_fd_sc_hd__inv_2
X_3773_ _6775_/Q _3884_/A2 _3883_/A2 _6763_/Q VGND VGND VPWR VPWR _3773_/X sky130_fd_sc_hd__a22o_2
X_6492_ _6557_/A VGND VGND VPWR VPWR _6492_/Y sky130_fd_sc_hd__inv_2
X_7113_ _7276_/CLK _7113_/D _6393_/Y VGND VGND VPWR VPWR _7113_/Q sky130_fd_sc_hd__dfrtp_2
Xoutput478 _5663_/A VGND VGND VPWR VPWR alu_result_out[28] sky130_fd_sc_hd__clkdlybuf4s25_1
Xoutput467 _5657_/C VGND VGND VPWR VPWR alu_result_out[18] sky130_fd_sc_hd__clkdlybuf4s25_1
X_4325_ _7354_/Q _4337_/B _4323_/X _4324_/X VGND VGND VPWR VPWR _4325_/X sky130_fd_sc_hd__a211o_2
XFILLER_99_442 VGND VGND VPWR VPWR sky130_fd_sc_hd__decap_3
XFILLER_59_306 VGND VGND VPWR VPWR sky130_fd_sc_hd__decap_3
XFILLER_87_626 VGND VGND VPWR VPWR sky130_fd_sc_hd__decap_3
Xoutput489 _5658_/C VGND VGND VPWR VPWR alu_result_out[9] sky130_fd_sc_hd__clkdlybuf4s25_1
XTAP_TAPCELL_ROW_74_1085 VGND VPWR sky130_fd_sc_hd__tapvpwrvgnd_1
XFILLER_99_497 VGND VGND VPWR VPWR sky130_fd_sc_hd__fill_1
XFILLER_99_475 VGND VGND VPWR VPWR sky130_fd_sc_hd__decap_3
XFILLER_101_425 VGND VGND VPWR VPWR sky130_fd_sc_hd__decap_3
XFILLER_86_125 VGND VGND VPWR VPWR sky130_fd_sc_hd__decap_3
X_7044_ _7392_/CLK _7044_/D _6324_/Y VGND VGND VPWR VPWR _7044_/Q sky130_fd_sc_hd__dfrtp_2
X_4256_ _4626_/B _4626_/C _4256_/C VGND VGND VPWR VPWR _4988_/A sky130_fd_sc_hd__and3_4
XFILLER_101_458 VGND VGND VPWR VPWR sky130_fd_sc_hd__decap_3
XFILLER_86_158 VGND VGND VPWR VPWR sky130_fd_sc_hd__fill_1
X_4187_ _7327_/Q _3958_/S _4495_/S _7295_/Q VGND VGND VPWR VPWR _4187_/X sky130_fd_sc_hd__a22o_2
XFILLER_103_24 VGND VGND VPWR VPWR sky130_fd_sc_hd__decap_3
XFILLER_55_523 VGND VGND VPWR VPWR sky130_fd_sc_hd__decap_3
XFILLER_103_57 VGND VGND VPWR VPWR sky130_fd_sc_hd__decap_3
XFILLER_42_206 VGND VGND VPWR VPWR sky130_fd_sc_hd__decap_3
XFILLER_70_515 VGND VGND VPWR VPWR sky130_fd_sc_hd__decap_3
XFILLER_70_526 VGND VGND VPWR VPWR sky130_fd_sc_hd__decap_3
XFILLER_82_386 VGND VGND VPWR VPWR sky130_fd_sc_hd__decap_3
XFILLER_42_239 VGND VGND VPWR VPWR sky130_fd_sc_hd__decap_3
XFILLER_70_559 VGND VGND VPWR VPWR sky130_fd_sc_hd__decap_3
XFILLER_11_615 VGND VGND VPWR VPWR sky130_fd_sc_hd__fill_1
X_6828_ _6974_/CLK _6828_/D VGND VGND VPWR VPWR _6828_/Q sky130_fd_sc_hd__dfxtp_2
XFILLER_10_125 VGND VGND VPWR VPWR sky130_fd_sc_hd__decap_3
XFILLER_11_626 VGND VGND VPWR VPWR sky130_fd_sc_hd__decap_3
XFILLER_50_261 VGND VGND VPWR VPWR sky130_fd_sc_hd__decap_3
X_6759_ _6963_/CLK _6759_/D VGND VGND VPWR VPWR _6759_/Q sky130_fd_sc_hd__dfxtp_2
XFILLER_2_368 VGND VGND VPWR VPWR sky130_fd_sc_hd__fill_2
XFILLER_77_125 VGND VGND VPWR VPWR sky130_fd_sc_hd__decap_3
XFILLER_77_158 VGND VGND VPWR VPWR sky130_fd_sc_hd__decap_3
XFILLER_77_169 VGND VGND VPWR VPWR sky130_fd_sc_hd__decap_3
XFILLER_93_629 VGND VGND VPWR VPWR sky130_fd_sc_hd__decap_3
XFILLER_37_51 VGND VGND VPWR VPWR sky130_fd_sc_hd__decap_3
XFILLER_58_361 VGND VGND VPWR VPWR sky130_fd_sc_hd__decap_3
XFILLER_58_394 VGND VGND VPWR VPWR sky130_fd_sc_hd__decap_3
XFILLER_73_320 VGND VGND VPWR VPWR sky130_fd_sc_hd__decap_3
XFILLER_92_128 VGND VGND VPWR VPWR sky130_fd_sc_hd__decap_3
XFILLER_18_269 VGND VGND VPWR VPWR sky130_fd_sc_hd__decap_3
XFILLER_46_578 VGND VGND VPWR VPWR sky130_fd_sc_hd__fill_1
XFILLER_46_589 VGND VGND VPWR VPWR sky130_fd_sc_hd__decap_3
XFILLER_73_364 VGND VGND VPWR VPWR sky130_fd_sc_hd__decap_3
XTAP_TAPCELL_ROW_16_415 VGND VPWR sky130_fd_sc_hd__tapvpwrvgnd_1
XFILLER_26_291 VGND VGND VPWR VPWR sky130_fd_sc_hd__decap_3
XFILLER_33_228 VGND VGND VPWR VPWR sky130_fd_sc_hd__decap_3
XFILLER_61_559 VGND VGND VPWR VPWR sky130_fd_sc_hd__fill_1
XTAP_TAPCELL_ROW_44_746 VGND VPWR sky130_fd_sc_hd__tapvpwrvgnd_1
XTAP_TAPCELL_ROW_44_735 VGND VPWR sky130_fd_sc_hd__tapvpwrvgnd_1
XFILLER_14_497 VGND VGND VPWR VPWR sky130_fd_sc_hd__decap_3
XFILLER_41_272 VGND VGND VPWR VPWR sky130_fd_sc_hd__decap_3
XFILLER_5_140 VGND VGND VPWR VPWR sky130_fd_sc_hd__decap_3
XFILLER_69_615 VGND VGND VPWR VPWR sky130_fd_sc_hd__fill_1
XFILLER_69_626 VGND VGND VPWR VPWR sky130_fd_sc_hd__decap_3
XFILLER_96_412 VGND VGND VPWR VPWR sky130_fd_sc_hd__decap_3
XFILLER_78_80 VGND VGND VPWR VPWR sky130_fd_sc_hd__decap_3
X_5090_ _5146_/B1 _5083_/X _5085_/X _5089_/Y VGND VGND VPWR VPWR _5658_/C sky130_fd_sc_hd__a31o_2
X_4110_ _4376_/A _4141_/A _4141_/B _4142_/C VGND VGND VPWR VPWR _4111_/B sky130_fd_sc_hd__or4_4
XFILLER_56_309 VGND VGND VPWR VPWR sky130_fd_sc_hd__decap_3
X_4041_ _7245_/Q _4430_/A2 _4420_/B1 _7149_/Q VGND VGND VPWR VPWR _4041_/X sky130_fd_sc_hd__a22o_2
XFILLER_37_501 VGND VGND VPWR VPWR sky130_fd_sc_hd__decap_3
XFILLER_49_361 VGND VGND VPWR VPWR sky130_fd_sc_hd__decap_3
XFILLER_83_128 VGND VGND VPWR VPWR sky130_fd_sc_hd__decap_3
XFILLER_37_567 VGND VGND VPWR VPWR sky130_fd_sc_hd__decap_3
XFILLER_64_331 VGND VGND VPWR VPWR sky130_fd_sc_hd__decap_3
XFILLER_24_206 VGND VGND VPWR VPWR sky130_fd_sc_hd__decap_3
XFILLER_37_589 VGND VGND VPWR VPWR sky130_fd_sc_hd__decap_3
XFILLER_64_386 VGND VGND VPWR VPWR sky130_fd_sc_hd__decap_3
XFILLER_91_172 VGND VGND VPWR VPWR sky130_fd_sc_hd__decap_3
XTAP_TAPCELL_ROW_108_1479 VGND VPWR sky130_fd_sc_hd__tapvpwrvgnd_1
XFILLER_24_239 VGND VGND VPWR VPWR sky130_fd_sc_hd__fill_2
XFILLER_91_194 VGND VGND VPWR VPWR sky130_fd_sc_hd__decap_3
X_4943_ _4943_/A _4943_/B VGND VGND VPWR VPWR _4944_/C sky130_fd_sc_hd__nor2_2
XFILLER_60_592 VGND VGND VPWR VPWR sky130_fd_sc_hd__decap_3
X_6613_ _6613_/A VGND VGND VPWR VPWR _6613_/Y sky130_fd_sc_hd__inv_2
X_4874_ _4814_/A _4849_/Y _4872_/X _4873_/X VGND VGND VPWR VPWR _4874_/X sky130_fd_sc_hd__o31a_2
X_3825_ _6749_/Q _3881_/A2 _3883_/A2 _6737_/Q VGND VGND VPWR VPWR _3825_/X sky130_fd_sc_hd__a22o_2
X_6544_ _6669_/A VGND VGND VPWR VPWR _6544_/Y sky130_fd_sc_hd__inv_2
X_3756_ _6798_/Q _3913_/A2 _3823_/A2 _6708_/Q _3755_/X VGND VGND VPWR VPWR _3756_/X
+ sky130_fd_sc_hd__a221o_2
X_6475_ _6638_/A VGND VGND VPWR VPWR _6475_/Y sky130_fd_sc_hd__inv_2
XTAP_TAPCELL_ROW_76_1114 VGND VPWR sky130_fd_sc_hd__tapvpwrvgnd_1
XTAP_TAPCELL_ROW_76_1103 VGND VPWR sky130_fd_sc_hd__tapvpwrvgnd_1
XFILLER_59_103 VGND VGND VPWR VPWR sky130_fd_sc_hd__fill_1
XFILLER_101_200 VGND VGND VPWR VPWR sky130_fd_sc_hd__decap_3
XFILLER_58_39 VGND VGND VPWR VPWR sky130_fd_sc_hd__decap_3
XFILLER_87_434 VGND VGND VPWR VPWR sky130_fd_sc_hd__decap_3
X_5288_ _5288_/A0 _3993_/X _5292_/S VGND VGND VPWR VPWR _7185_/D sky130_fd_sc_hd__mux2_2
X_4308_ _7192_/Q _4414_/B1 _3380_/Y _7384_/Q VGND VGND VPWR VPWR _4308_/X sky130_fd_sc_hd__a22o_2
XFILLER_101_255 VGND VGND VPWR VPWR sky130_fd_sc_hd__decap_3
XFILLER_59_169 VGND VGND VPWR VPWR sky130_fd_sc_hd__decap_3
XFILLER_75_607 VGND VGND VPWR VPWR sky130_fd_sc_hd__decap_3
X_7027_ _7372_/CLK _7027_/D _6307_/Y VGND VGND VPWR VPWR _7027_/Q sky130_fd_sc_hd__dfrtp_2
X_4239_ _4628_/A _4629_/B VGND VGND VPWR VPWR _5018_/B sky130_fd_sc_hd__nor2_2
XFILLER_101_299 VGND VGND VPWR VPWR sky130_fd_sc_hd__fill_2
XFILLER_74_139 VGND VGND VPWR VPWR sky130_fd_sc_hd__fill_1
XTAP_TAPCELL_ROW_87_1232 VGND VPWR sky130_fd_sc_hd__tapvpwrvgnd_1
XFILLER_15_217 VGND VGND VPWR VPWR sky130_fd_sc_hd__decap_3
XFILLER_28_589 VGND VGND VPWR VPWR sky130_fd_sc_hd__decap_3
XFILLER_70_301 VGND VGND VPWR VPWR sky130_fd_sc_hd__decap_3
XFILLER_15_239 VGND VGND VPWR VPWR sky130_fd_sc_hd__decap_3
XFILLER_43_537 VGND VGND VPWR VPWR sky130_fd_sc_hd__fill_2
XFILLER_70_334 VGND VGND VPWR VPWR sky130_fd_sc_hd__decap_3
XFILLER_23_250 VGND VGND VPWR VPWR sky130_fd_sc_hd__decap_3
XFILLER_30_209 VGND VGND VPWR VPWR sky130_fd_sc_hd__decap_3
XFILLER_70_356 VGND VGND VPWR VPWR sky130_fd_sc_hd__decap_3
XTAP_TAPCELL_ROW_41_705 VGND VPWR sky130_fd_sc_hd__tapvpwrvgnd_1
XFILLER_11_423 VGND VGND VPWR VPWR sky130_fd_sc_hd__decap_3
XFILLER_70_389 VGND VGND VPWR VPWR sky130_fd_sc_hd__decap_3
XFILLER_11_445 VGND VGND VPWR VPWR sky130_fd_sc_hd__decap_3
XFILLER_11_467 VGND VGND VPWR VPWR sky130_fd_sc_hd__decap_3
XFILLER_7_449 VGND VGND VPWR VPWR sky130_fd_sc_hd__decap_3
XTAP_TAPCELL_ROW_98_1361 VGND VPWR sky130_fd_sc_hd__tapvpwrvgnd_1
XTAP_TAPCELL_ROW_21_473 VGND VPWR sky130_fd_sc_hd__tapvpwrvgnd_1
XFILLER_3_600 VGND VGND VPWR VPWR sky130_fd_sc_hd__decap_3
XFILLER_3_644 VGND VGND VPWR VPWR sky130_fd_sc_hd__decap_3
XFILLER_2_165 VGND VGND VPWR VPWR sky130_fd_sc_hd__decap_3
XFILLER_97_209 VGND VGND VPWR VPWR sky130_fd_sc_hd__fill_2
XFILLER_38_309 VGND VGND VPWR VPWR sky130_fd_sc_hd__decap_3
XFILLER_66_607 VGND VGND VPWR VPWR sky130_fd_sc_hd__decap_3
XFILLER_17_9 VGND VGND VPWR VPWR sky130_fd_sc_hd__fill_1
XFILLER_48_83 VGND VGND VPWR VPWR sky130_fd_sc_hd__fill_1
XFILLER_65_106 VGND VGND VPWR VPWR sky130_fd_sc_hd__decap_3
XFILLER_78_489 VGND VGND VPWR VPWR sky130_fd_sc_hd__fill_2
XFILLER_0_24 VGND VGND VPWR VPWR sky130_fd_sc_hd__decap_3
XFILLER_19_545 VGND VGND VPWR VPWR sky130_fd_sc_hd__decap_3
XFILLER_65_139 VGND VGND VPWR VPWR sky130_fd_sc_hd__decap_3
XFILLER_0_57 VGND VGND VPWR VPWR sky130_fd_sc_hd__fill_2
XFILLER_19_567 VGND VGND VPWR VPWR sky130_fd_sc_hd__fill_1
XTAP_TAPCELL_ROW_29_573 VGND VPWR sky130_fd_sc_hd__tapvpwrvgnd_1
XFILLER_61_334 VGND VGND VPWR VPWR sky130_fd_sc_hd__fill_2
XTAP_TAPCELL_ROW_57_893 VGND VPWR sky130_fd_sc_hd__tapvpwrvgnd_1
XFILLER_61_367 VGND VGND VPWR VPWR sky130_fd_sc_hd__decap_3
XFILLER_9_11 VGND VGND VPWR VPWR sky130_fd_sc_hd__fill_1
XFILLER_14_261 VGND VGND VPWR VPWR sky130_fd_sc_hd__decap_3
XFILLER_14_283 VGND VGND VPWR VPWR sky130_fd_sc_hd__decap_3
XFILLER_42_592 VGND VGND VPWR VPWR sky130_fd_sc_hd__fill_2
X_3610_ _3610_/A _3610_/B VGND VGND VPWR VPWR _3610_/Y sky130_fd_sc_hd__nor2_2
XPHY_EDGE_ROW_104_Right_104 VGND VGND VPWR VPWR sky130_fd_sc_hd__decap_3
X_3541_ _4376_/A _3541_/B _4460_/B VGND VGND VPWR VPWR _3541_/X sky130_fd_sc_hd__or3b_4
XFILLER_6_460 VGND VGND VPWR VPWR sky130_fd_sc_hd__decap_3
Xhold906 _6693_/Q VGND VGND VPWR VPWR hold906/X sky130_fd_sc_hd__dlygate4sd3_1
Xhold917 _6698_/Q VGND VGND VPWR VPWR hold917/X sky130_fd_sc_hd__dlygate4sd3_1
Xhold928 _6705_/Q VGND VGND VPWR VPWR hold928/X sky130_fd_sc_hd__dlygate4sd3_1
Xhold939 _7014_/Q VGND VGND VPWR VPWR _5628_/A sky130_fd_sc_hd__dlygate4sd3_1
X_6260_ _6260_/A VGND VGND VPWR VPWR _6260_/Y sky130_fd_sc_hd__inv_2
X_3472_ _7216_/Q _4349_/B1 _4341_/B1 _7120_/Q VGND VGND VPWR VPWR _3472_/X sky130_fd_sc_hd__a22o_2
X_5211_ _5211_/A _5225_/B VGND VGND VPWR VPWR _7223_/D sky130_fd_sc_hd__and2_2
XFILLER_69_445 VGND VGND VPWR VPWR sky130_fd_sc_hd__decap_3
X_5142_ _5142_/A0 _3993_/X _5142_/S VGND VGND VPWR VPWR _7249_/D sky130_fd_sc_hd__mux2_2
XFILLER_29_309 VGND VGND VPWR VPWR sky130_fd_sc_hd__fill_2
XTAP_TAPCELL_ROW_71_1055 VGND VPWR sky130_fd_sc_hd__tapvpwrvgnd_1
XFILLER_96_253 VGND VGND VPWR VPWR sky130_fd_sc_hd__decap_3
XFILLER_56_117 VGND VGND VPWR VPWR sky130_fd_sc_hd__decap_3
XFILLER_57_629 VGND VGND VPWR VPWR sky130_fd_sc_hd__decap_3
X_5073_ _5073_/A _5073_/B VGND VGND VPWR VPWR _5073_/Y sky130_fd_sc_hd__xnor2_2
XFILLER_80_610 VGND VGND VPWR VPWR sky130_fd_sc_hd__decap_3
XFILLER_25_537 VGND VGND VPWR VPWR sky130_fd_sc_hd__fill_2
XFILLER_52_312 VGND VGND VPWR VPWR sky130_fd_sc_hd__decap_3
XFILLER_64_172 VGND VGND VPWR VPWR sky130_fd_sc_hd__decap_3
XFILLER_80_643 VGND VGND VPWR VPWR sky130_fd_sc_hd__fill_1
XFILLER_12_209 VGND VGND VPWR VPWR sky130_fd_sc_hd__decap_3
XFILLER_100_14 VGND VGND VPWR VPWR sky130_fd_sc_hd__decap_3
XFILLER_40_529 VGND VGND VPWR VPWR sky130_fd_sc_hd__decap_3
X_4926_ _4948_/A _4920_/Y _4925_/X VGND VGND VPWR VPWR _4926_/Y sky130_fd_sc_hd__o21ai_2
XTAP_TAPCELL_ROW_82_1173 VGND VPWR sky130_fd_sc_hd__tapvpwrvgnd_1
XFILLER_33_592 VGND VGND VPWR VPWR sky130_fd_sc_hd__decap_3
X_4857_ _4983_/A _5655_/D _3749_/Y VGND VGND VPWR VPWR _4857_/X sky130_fd_sc_hd__or3b_4
XFILLER_20_253 VGND VGND VPWR VPWR sky130_fd_sc_hd__decap_3
XFILLER_20_264 VGND VGND VPWR VPWR sky130_fd_sc_hd__decap_3
XFILLER_60_29 VGND VGND VPWR VPWR sky130_fd_sc_hd__decap_3
X_3808_ _6929_/Q _3888_/A2 _3926_/B1 _6793_/Q _3807_/X VGND VGND VPWR VPWR _3808_/X
+ sky130_fd_sc_hd__a221o_2
X_6527_ _6625_/A VGND VGND VPWR VPWR _6527_/Y sky130_fd_sc_hd__inv_2
X_4788_ _4788_/A _4788_/B VGND VGND VPWR VPWR _4788_/Y sky130_fd_sc_hd__nand2_2
X_3739_ _6936_/Q _3888_/A2 _3889_/A2 _6800_/Q VGND VGND VPWR VPWR _3739_/X sky130_fd_sc_hd__a22o_2
X_6458_ _6652_/A VGND VGND VPWR VPWR _6458_/Y sky130_fd_sc_hd__inv_2
X_6389_ _6618_/A VGND VGND VPWR VPWR _6389_/Y sky130_fd_sc_hd__inv_2
X_5409_ _5409_/A0 _5079_/X _5427_/S VGND VGND VPWR VPWR _7129_/D sky130_fd_sc_hd__mux2_2
XFILLER_0_614 VGND VGND VPWR VPWR sky130_fd_sc_hd__fill_2
XFILLER_102_520 VGND VGND VPWR VPWR sky130_fd_sc_hd__decap_3
XFILLER_102_542 VGND VGND VPWR VPWR sky130_fd_sc_hd__decap_3
XFILLER_102_564 VGND VGND VPWR VPWR sky130_fd_sc_hd__fill_2
XFILLER_87_231 VGND VGND VPWR VPWR sky130_fd_sc_hd__fill_1
XFILLER_47_106 VGND VGND VPWR VPWR sky130_fd_sc_hd__decap_3
XFILLER_47_128 VGND VGND VPWR VPWR sky130_fd_sc_hd__decap_3
XFILLER_28_342 VGND VGND VPWR VPWR sky130_fd_sc_hd__decap_3
XFILLER_43_301 VGND VGND VPWR VPWR sky130_fd_sc_hd__decap_3
XFILLER_90_429 VGND VGND VPWR VPWR sky130_fd_sc_hd__decap_3
XFILLER_18_97 VGND VGND VPWR VPWR sky130_fd_sc_hd__fill_1
XFILLER_28_386 VGND VGND VPWR VPWR sky130_fd_sc_hd__decap_3
XFILLER_43_334 VGND VGND VPWR VPWR sky130_fd_sc_hd__fill_2
XFILLER_55_172 VGND VGND VPWR VPWR sky130_fd_sc_hd__decap_3
XFILLER_71_632 VGND VGND VPWR VPWR sky130_fd_sc_hd__decap_3
XFILLER_43_345 VGND VGND VPWR VPWR sky130_fd_sc_hd__decap_3
XFILLER_70_153 VGND VGND VPWR VPWR sky130_fd_sc_hd__decap_3
XTAP_TAPCELL_ROW_54_852 VGND VPWR sky130_fd_sc_hd__tapvpwrvgnd_1
XTAP_TAPCELL_ROW_26_532 VGND VPWR sky130_fd_sc_hd__tapvpwrvgnd_1
XFILLER_34_52 VGND VGND VPWR VPWR sky130_fd_sc_hd__fill_1
XFILLER_70_175 VGND VGND VPWR VPWR sky130_fd_sc_hd__decap_3
XFILLER_34_85 VGND VGND VPWR VPWR sky130_fd_sc_hd__decap_3
XFILLER_70_197 VGND VGND VPWR VPWR sky130_fd_sc_hd__decap_3
XFILLER_11_242 VGND VGND VPWR VPWR sky130_fd_sc_hd__decap_3
XFILLER_11_275 VGND VGND VPWR VPWR sky130_fd_sc_hd__decap_3
XFILLER_7_202 VGND VGND VPWR VPWR sky130_fd_sc_hd__decap_3
XFILLER_7_213 VGND VGND VPWR VPWR sky130_fd_sc_hd__decap_3
XFILLER_50_51 VGND VGND VPWR VPWR sky130_fd_sc_hd__fill_2
XFILLER_7_246 VGND VGND VPWR VPWR sky130_fd_sc_hd__decap_3
XFILLER_7_279 VGND VGND VPWR VPWR sky130_fd_sc_hd__fill_1
XFILLER_59_71 VGND VGND VPWR VPWR sky130_fd_sc_hd__decap_3
XFILLER_105_391 VGND VGND VPWR VPWR sky130_fd_sc_hd__fill_1
XFILLER_59_93 VGND VGND VPWR VPWR sky130_fd_sc_hd__fill_2
XFILLER_78_242 VGND VGND VPWR VPWR sky130_fd_sc_hd__fill_1
XFILLER_39_629 VGND VGND VPWR VPWR sky130_fd_sc_hd__decap_3
XFILLER_93_201 VGND VGND VPWR VPWR sky130_fd_sc_hd__decap_3
XFILLER_15_6 VGND VGND VPWR VPWR sky130_fd_sc_hd__decap_3
XFILLER_19_331 VGND VGND VPWR VPWR sky130_fd_sc_hd__decap_3
XFILLER_38_139 VGND VGND VPWR VPWR sky130_fd_sc_hd__fill_1
XFILLER_66_459 VGND VGND VPWR VPWR sky130_fd_sc_hd__decap_3
XFILLER_19_364 VGND VGND VPWR VPWR sky130_fd_sc_hd__decap_3
XFILLER_81_418 VGND VGND VPWR VPWR sky130_fd_sc_hd__decap_3
XFILLER_34_312 VGND VGND VPWR VPWR sky130_fd_sc_hd__decap_3
XFILLER_46_194 VGND VGND VPWR VPWR sky130_fd_sc_hd__fill_2
XFILLER_62_621 VGND VGND VPWR VPWR sky130_fd_sc_hd__decap_3
XTAP_TAPCELL_ROW_105_1438 VGND VPWR sky130_fd_sc_hd__tapvpwrvgnd_1
XFILLER_34_356 VGND VGND VPWR VPWR sky130_fd_sc_hd__decap_3
XFILLER_15_570 VGND VGND VPWR VPWR sky130_fd_sc_hd__decap_3
XFILLER_61_164 VGND VGND VPWR VPWR sky130_fd_sc_hd__decap_3
XFILLER_61_175 VGND VGND VPWR VPWR sky130_fd_sc_hd__decap_3
XFILLER_61_197 VGND VGND VPWR VPWR sky130_fd_sc_hd__decap_3
X_4711_ _7005_/Q _7006_/Q _4775_/A VGND VGND VPWR VPWR _4738_/A sky130_fd_sc_hd__and3_2
X_4642_ _4207_/A _4642_/B VGND VGND VPWR VPWR _4888_/A sky130_fd_sc_hd__and2b_2
XFILLER_30_595 VGND VGND VPWR VPWR sky130_fd_sc_hd__decap_3
X_7361_ _7361_/CLK _7361_/D _6641_/Y VGND VGND VPWR VPWR _7361_/Q sky130_fd_sc_hd__dfrtp_2
Xhold703 _6828_/Q VGND VGND VPWR VPWR _6828_/D sky130_fd_sc_hd__dlygate4sd3_1
X_4573_ _7294_/Q _4573_/B VGND VGND VPWR VPWR _7294_/D sky130_fd_sc_hd__and2_2
X_7292_ _7356_/CLK _7292_/D _6572_/Y VGND VGND VPWR VPWR _7292_/Q sky130_fd_sc_hd__dfrtp_2
Xhold714 _6777_/Q VGND VGND VPWR VPWR _6777_/D sky130_fd_sc_hd__dlygate4sd3_1
Xhold725 _6835_/Q VGND VGND VPWR VPWR _6835_/D sky130_fd_sc_hd__dlygate4sd3_1
Xhold736 _6886_/Q VGND VGND VPWR VPWR _6886_/D sky130_fd_sc_hd__dlygate4sd3_1
X_6312_ _6628_/A VGND VGND VPWR VPWR _6312_/Y sky130_fd_sc_hd__inv_2
Xhold747 _6735_/Q VGND VGND VPWR VPWR _6735_/D sky130_fd_sc_hd__dlygate4sd3_1
Xhold758 _6879_/Q VGND VGND VPWR VPWR _6879_/D sky130_fd_sc_hd__dlygate4sd3_1
Xhold769 _6885_/Q VGND VGND VPWR VPWR _6885_/D sky130_fd_sc_hd__dlygate4sd3_1
X_3455_ _7346_/Q _4337_/B _3454_/X VGND VGND VPWR VPWR _3455_/X sky130_fd_sc_hd__a21o_2
XFILLER_103_317 VGND VGND VPWR VPWR sky130_fd_sc_hd__decap_3
XFILLER_69_242 VGND VGND VPWR VPWR sky130_fd_sc_hd__decap_3
XFILLER_69_253 VGND VGND VPWR VPWR sky130_fd_sc_hd__decap_3
X_3386_ _3561_/A _3386_/B VGND VGND VPWR VPWR _3386_/Y sky130_fd_sc_hd__nand2_2
X_5125_ _5156_/S _5125_/B VGND VGND VPWR VPWR _5125_/Y sky130_fd_sc_hd__nand2_2
XFILLER_97_573 VGND VGND VPWR VPWR sky130_fd_sc_hd__decap_3
XFILLER_29_128 VGND VGND VPWR VPWR sky130_fd_sc_hd__decap_3
XFILLER_57_459 VGND VGND VPWR VPWR sky130_fd_sc_hd__decap_3
X_5056_ _3536_/B _4619_/B _5052_/X _5055_/X VGND VGND VPWR VPWR _5056_/X sky130_fd_sc_hd__o31a_2
XFILLER_84_256 VGND VGND VPWR VPWR sky130_fd_sc_hd__decap_3
XFILLER_25_334 VGND VGND VPWR VPWR sky130_fd_sc_hd__fill_2
XFILLER_37_183 VGND VGND VPWR VPWR sky130_fd_sc_hd__decap_3
XFILLER_53_632 VGND VGND VPWR VPWR sky130_fd_sc_hd__decap_3
XTAP_TAPCELL_ROW_84_1202 VGND VPWR sky130_fd_sc_hd__tapvpwrvgnd_1
XFILLER_25_356 VGND VGND VPWR VPWR sky130_fd_sc_hd__decap_3
XFILLER_80_451 VGND VGND VPWR VPWR sky130_fd_sc_hd__fill_1
XFILLER_40_315 VGND VGND VPWR VPWR sky130_fd_sc_hd__fill_2
XFILLER_52_186 VGND VGND VPWR VPWR sky130_fd_sc_hd__decap_3
XTAP_TAPCELL_ROW_51_822 VGND VPWR sky130_fd_sc_hd__tapvpwrvgnd_1
XTAP_TAPCELL_ROW_23_502 VGND VPWR sky130_fd_sc_hd__tapvpwrvgnd_1
X_4909_ _4909_/A _4909_/B _4909_/C VGND VGND VPWR VPWR _4910_/B sky130_fd_sc_hd__or3_2
XFILLER_107_623 VGND VGND VPWR VPWR sky130_fd_sc_hd__decap_3
XTAP_TAPCELL_ROW_31_590 VGND VPWR sky130_fd_sc_hd__tapvpwrvgnd_1
XFILLER_106_100 VGND VGND VPWR VPWR sky130_fd_sc_hd__decap_3
XFILLER_20_32 VGND VGND VPWR VPWR sky130_fd_sc_hd__decap_3
XFILLER_4_238 VGND VGND VPWR VPWR sky130_fd_sc_hd__fill_2
XTAP_TAPCELL_ROW_95_1331 VGND VPWR sky130_fd_sc_hd__tapvpwrvgnd_1
XFILLER_20_54 VGND VGND VPWR VPWR sky130_fd_sc_hd__decap_3
XFILLER_0_477 VGND VGND VPWR VPWR sky130_fd_sc_hd__decap_3
XFILLER_29_30 VGND VGND VPWR VPWR sky130_fd_sc_hd__decap_3
XFILLER_48_404 VGND VGND VPWR VPWR sky130_fd_sc_hd__fill_2
XTAP_TAPCELL_ROW_59_911 VGND VPWR sky130_fd_sc_hd__tapvpwrvgnd_1
XFILLER_75_223 VGND VGND VPWR VPWR sky130_fd_sc_hd__fill_1
XFILLER_28_150 VGND VGND VPWR VPWR sky130_fd_sc_hd__decap_3
XFILLER_75_256 VGND VGND VPWR VPWR sky130_fd_sc_hd__decap_3
XTAP_TAPCELL_ROW_3_271 VGND VPWR sky130_fd_sc_hd__tapvpwrvgnd_1
XFILLER_16_312 VGND VGND VPWR VPWR sky130_fd_sc_hd__fill_1
XFILLER_75_289 VGND VGND VPWR VPWR sky130_fd_sc_hd__decap_3
XFILLER_90_226 VGND VGND VPWR VPWR sky130_fd_sc_hd__decap_3
Xplace407 _3562_/A VGND VGND VPWR VPWR _3488_/B sky130_fd_sc_hd__buf_2
Xplace418 _3956_/S VGND VGND VPWR VPWR _3943_/S sky130_fd_sc_hd__buf_2
Xplace429 _4261_/B1 VGND VGND VPWR VPWR _4459_/C1 sky130_fd_sc_hd__buf_2
XFILLER_16_356 VGND VGND VPWR VPWR sky130_fd_sc_hd__decap_3
XFILLER_43_131 VGND VGND VPWR VPWR sky130_fd_sc_hd__decap_3
XFILLER_44_643 VGND VGND VPWR VPWR sky130_fd_sc_hd__fill_1
XFILLER_90_248 VGND VGND VPWR VPWR sky130_fd_sc_hd__decap_3
XFILLER_43_186 VGND VGND VPWR VPWR sky130_fd_sc_hd__decap_3
XFILLER_71_473 VGND VGND VPWR VPWR sky130_fd_sc_hd__decap_3
XFILLER_31_337 VGND VGND VPWR VPWR sky130_fd_sc_hd__decap_3
XFILLER_43_197 VGND VGND VPWR VPWR sky130_fd_sc_hd__decap_3
XFILLER_12_573 VGND VGND VPWR VPWR sky130_fd_sc_hd__decap_3
XFILLER_8_500 VGND VGND VPWR VPWR sky130_fd_sc_hd__decap_3
XFILLER_12_595 VGND VGND VPWR VPWR sky130_fd_sc_hd__decap_3
XFILLER_8_533 VGND VGND VPWR VPWR sky130_fd_sc_hd__decap_3
XTAP_TAPCELL_ROW_100_1379 VGND VPWR sky130_fd_sc_hd__tapvpwrvgnd_1
XANTENNA_5 _6694_/Q VGND VGND VPWR VPWR sky130_fd_sc_hd__diode_2
XFILLER_98_326 VGND VGND VPWR VPWR sky130_fd_sc_hd__fill_1
XFILLER_79_595 VGND VGND VPWR VPWR sky130_fd_sc_hd__fill_1
XFILLER_66_212 VGND VGND VPWR VPWR sky130_fd_sc_hd__fill_2
XFILLER_66_223 VGND VGND VPWR VPWR sky130_fd_sc_hd__decap_3
XFILLER_94_554 VGND VGND VPWR VPWR sky130_fd_sc_hd__decap_3
XFILLER_66_267 VGND VGND VPWR VPWR sky130_fd_sc_hd__fill_2
XFILLER_19_161 VGND VGND VPWR VPWR sky130_fd_sc_hd__decap_3
XFILLER_19_172 VGND VGND VPWR VPWR sky130_fd_sc_hd__fill_2
XFILLER_35_632 VGND VGND VPWR VPWR sky130_fd_sc_hd__decap_3
XFILLER_47_492 VGND VGND VPWR VPWR sky130_fd_sc_hd__decap_3
XFILLER_81_237 VGND VGND VPWR VPWR sky130_fd_sc_hd__fill_2
XFILLER_94_598 VGND VGND VPWR VPWR sky130_fd_sc_hd__fill_2
X_6930_ clkload5/A _6930_/D VGND VGND VPWR VPWR _6930_/Q sky130_fd_sc_hd__dfxtp_2
XFILLER_19_194 VGND VGND VPWR VPWR sky130_fd_sc_hd__decap_3
XFILLER_62_451 VGND VGND VPWR VPWR sky130_fd_sc_hd__decap_3
X_6861_ clkload7/A _6861_/D VGND VGND VPWR VPWR _6861_/Q sky130_fd_sc_hd__dfxtp_2
XFILLER_22_315 VGND VGND VPWR VPWR sky130_fd_sc_hd__fill_1
XFILLER_34_153 VGND VGND VPWR VPWR sky130_fd_sc_hd__decap_3
XFILLER_34_175 VGND VGND VPWR VPWR sky130_fd_sc_hd__decap_3
XFILLER_50_602 VGND VGND VPWR VPWR sky130_fd_sc_hd__decap_3
X_6792_ _7071_/CLK _6792_/D VGND VGND VPWR VPWR _6792_/Q sky130_fd_sc_hd__dfxtp_2
XFILLER_22_337 VGND VGND VPWR VPWR sky130_fd_sc_hd__fill_1
XFILLER_34_197 VGND VGND VPWR VPWR sky130_fd_sc_hd__decap_3
XFILLER_50_635 VGND VGND VPWR VPWR sky130_fd_sc_hd__decap_3
XFILLER_62_495 VGND VGND VPWR VPWR sky130_fd_sc_hd__decap_3
X_5674_ _7343_/Q hold911/X _5697_/S VGND VGND VPWR VPWR _6687_/D sky130_fd_sc_hd__mux2_2
X_4625_ _5099_/A _4625_/A2 _4624_/B _4624_/X VGND VGND VPWR VPWR _4916_/A sky130_fd_sc_hd__a31oi_4
X_7344_ _7352_/CLK _7344_/D _6624_/Y VGND VGND VPWR VPWR _7344_/Q sky130_fd_sc_hd__dfrtp_2
X_4556_ _4556_/A _4573_/B VGND VGND VPWR VPWR _7302_/D sky130_fd_sc_hd__and2_2
X_3507_ _3458_/Y _3505_/X _3506_/Y VGND VGND VPWR VPWR _3508_/B sky130_fd_sc_hd__o21a_2
XFILLER_104_626 VGND VGND VPWR VPWR sky130_fd_sc_hd__decap_3
X_7275_ _7363_/CLK _7275_/D _6555_/Y VGND VGND VPWR VPWR _7275_/Q sky130_fd_sc_hd__dfrtp_2
Xhold588 _6967_/Q VGND VGND VPWR VPWR _6967_/D sky130_fd_sc_hd__dlygate4sd3_1
XFILLER_106_35 VGND VGND VPWR VPWR sky130_fd_sc_hd__decap_3
Xhold599 _6946_/Q VGND VGND VPWR VPWR _6946_/D sky130_fd_sc_hd__dlygate4sd3_1
X_3438_ _7314_/Q _3989_/S _4346_/B1 _7346_/Q _4338_/C1 VGND VGND VPWR VPWR _3438_/X
+ sky130_fd_sc_hd__a221o_2
XFILLER_103_169 VGND VGND VPWR VPWR sky130_fd_sc_hd__decap_3
XFILLER_106_68 VGND VGND VPWR VPWR sky130_fd_sc_hd__decap_3
Xhold1200 _7252_/Q VGND VGND VPWR VPWR _5132_/A0 sky130_fd_sc_hd__dlygate4sd3_1
X_3369_ _3371_/A _5668_/A VGND VGND VPWR VPWR _3560_/B sky130_fd_sc_hd__nand2_2
XTAP_TAPCELL_ROW_90_1272 VGND VPWR sky130_fd_sc_hd__tapvpwrvgnd_1
XFILLER_57_234 VGND VGND VPWR VPWR sky130_fd_sc_hd__decap_3
XFILLER_85_532 VGND VGND VPWR VPWR sky130_fd_sc_hd__decap_3
Xhold1211 _7298_/Q VGND VGND VPWR VPWR _4565_/A sky130_fd_sc_hd__dlygate4sd3_1
Xhold1222 _7360_/Q VGND VGND VPWR VPWR _3960_/A0 sky130_fd_sc_hd__dlygate4sd3_1
X_5108_ hold995/X _5107_/X _5159_/S VGND VGND VPWR VPWR _7255_/D sky130_fd_sc_hd__mux2_2
XFILLER_97_381 VGND VGND VPWR VPWR sky130_fd_sc_hd__decap_3
XFILLER_17_109 VGND VGND VPWR VPWR sky130_fd_sc_hd__decap_3
XFILLER_85_587 VGND VGND VPWR VPWR sky130_fd_sc_hd__decap_3
XFILLER_26_632 VGND VGND VPWR VPWR sky130_fd_sc_hd__decap_3
X_5039_ _4677_/B _3856_/X _5658_/B _5038_/X _5587_/B VGND VGND VPWR VPWR _5039_/X
+ sky130_fd_sc_hd__o32a_2
XTAP_TAPCELL_ROW_0_230 VGND VPWR sky130_fd_sc_hd__tapvpwrvgnd_1
XFILLER_25_153 VGND VGND VPWR VPWR sky130_fd_sc_hd__fill_1
XFILLER_25_175 VGND VGND VPWR VPWR sky130_fd_sc_hd__decap_3
XFILLER_13_337 VGND VGND VPWR VPWR sky130_fd_sc_hd__fill_2
XFILLER_13_348 VGND VGND VPWR VPWR sky130_fd_sc_hd__decap_3
XFILLER_41_635 VGND VGND VPWR VPWR sky130_fd_sc_hd__decap_3
XFILLER_31_53 VGND VGND VPWR VPWR sky130_fd_sc_hd__decap_3
XTAP_TAPCELL_ROW_8_330 VGND VPWR sky130_fd_sc_hd__tapvpwrvgnd_1
XFILLER_76_510 VGND VGND VPWR VPWR sky130_fd_sc_hd__decap_3
XFILLER_0_296 VGND VGND VPWR VPWR sky130_fd_sc_hd__decap_3
XFILLER_102_180 VGND VGND VPWR VPWR sky130_fd_sc_hd__fill_2
XFILLER_48_212 VGND VGND VPWR VPWR sky130_fd_sc_hd__decap_3
XFILLER_88_381 VGND VGND VPWR VPWR sky130_fd_sc_hd__decap_3
XFILLER_36_418 VGND VGND VPWR VPWR sky130_fd_sc_hd__fill_2
XFILLER_48_256 VGND VGND VPWR VPWR sky130_fd_sc_hd__decap_3
XFILLER_91_502 VGND VGND VPWR VPWR sky130_fd_sc_hd__fill_2
XFILLER_17_632 VGND VGND VPWR VPWR sky130_fd_sc_hd__decap_3
XFILLER_63_204 VGND VGND VPWR VPWR sky130_fd_sc_hd__decap_3
XFILLER_63_237 VGND VGND VPWR VPWR sky130_fd_sc_hd__fill_2
XFILLER_32_613 VGND VGND VPWR VPWR sky130_fd_sc_hd__decap_3
XFILLER_44_473 VGND VGND VPWR VPWR sky130_fd_sc_hd__decap_3
XTAP_TAPCELL_ROW_102_1408 VGND VPWR sky130_fd_sc_hd__tapvpwrvgnd_1
XFILLER_16_197 VGND VGND VPWR VPWR sky130_fd_sc_hd__fill_1
XFILLER_44_495 VGND VGND VPWR VPWR sky130_fd_sc_hd__decap_3
XFILLER_71_281 VGND VGND VPWR VPWR sky130_fd_sc_hd__decap_3
XFILLER_31_145 VGND VGND VPWR VPWR sky130_fd_sc_hd__decap_3
XFILLER_72_82 VGND VGND VPWR VPWR sky130_fd_sc_hd__fill_2
XFILLER_12_381 VGND VGND VPWR VPWR sky130_fd_sc_hd__decap_3
XFILLER_82_6 VGND VGND VPWR VPWR sky130_fd_sc_hd__decap_3
XFILLER_8_330 VGND VGND VPWR VPWR sky130_fd_sc_hd__decap_3
XTAP_TAPCELL_ROW_14_398 VGND VPWR sky130_fd_sc_hd__tapvpwrvgnd_1
XFILLER_8_352 VGND VGND VPWR VPWR sky130_fd_sc_hd__decap_3
XFILLER_8_363 VGND VGND VPWR VPWR sky130_fd_sc_hd__fill_1
XFILLER_8_385 VGND VGND VPWR VPWR sky130_fd_sc_hd__decap_3
X_4410_ _4411_/A _4411_/B VGND VGND VPWR VPWR _4788_/B sky130_fd_sc_hd__nor2_2
X_5390_ _5390_/A0 _4932_/X _5400_/S VGND VGND VPWR VPWR _7138_/D sky130_fd_sc_hd__mux2_2
X_4341_ _7255_/Q _4601_/S _4341_/B1 _7127_/Q _4340_/X VGND VGND VPWR VPWR _4365_/A
+ sky130_fd_sc_hd__a221o_2
XFILLER_99_635 VGND VGND VPWR VPWR sky130_fd_sc_hd__decap_3
XFILLER_99_613 VGND VGND VPWR VPWR sky130_fd_sc_hd__decap_3
X_7060_ clkload5/A _7060_/D _6340_/Y VGND VGND VPWR VPWR _7060_/Q sky130_fd_sc_hd__dfrtp_2
X_4272_ _4394_/A _4272_/B _4271_/X VGND VGND VPWR VPWR _4273_/D sky130_fd_sc_hd__or3b_2
XFILLER_101_629 VGND VGND VPWR VPWR sky130_fd_sc_hd__decap_3
XFILLER_86_307 VGND VGND VPWR VPWR sky130_fd_sc_hd__fill_1
XFILLER_100_128 VGND VGND VPWR VPWR sky130_fd_sc_hd__decap_3
XFILLER_39_223 VGND VGND VPWR VPWR sky130_fd_sc_hd__fill_1
XFILLER_79_381 VGND VGND VPWR VPWR sky130_fd_sc_hd__decap_3
XFILLER_39_267 VGND VGND VPWR VPWR sky130_fd_sc_hd__decap_3
XFILLER_94_351 VGND VGND VPWR VPWR sky130_fd_sc_hd__decap_3
XFILLER_27_418 VGND VGND VPWR VPWR sky130_fd_sc_hd__decap_3
XFILLER_82_524 VGND VGND VPWR VPWR sky130_fd_sc_hd__decap_3
XTAP_TAPCELL_ROW_68_1016 VGND VPWR sky130_fd_sc_hd__tapvpwrvgnd_1
XFILLER_54_248 VGND VGND VPWR VPWR sky130_fd_sc_hd__decap_3
X_6913_ clkload9/A _6913_/D VGND VGND VPWR VPWR _6913_/Q sky130_fd_sc_hd__dfxtp_2
XFILLER_23_613 VGND VGND VPWR VPWR sky130_fd_sc_hd__decap_3
XFILLER_22_112 VGND VGND VPWR VPWR sky130_fd_sc_hd__decap_3
XFILLER_23_635 VGND VGND VPWR VPWR sky130_fd_sc_hd__decap_3
XFILLER_50_432 VGND VGND VPWR VPWR sky130_fd_sc_hd__decap_3
XFILLER_52_19 VGND VGND VPWR VPWR sky130_fd_sc_hd__fill_1
X_6844_ clkload7/A _6844_/D VGND VGND VPWR VPWR _6844_/Q sky130_fd_sc_hd__dfxtp_2
X_6775_ _6966_/CLK _6775_/D VGND VGND VPWR VPWR _6775_/Q sky130_fd_sc_hd__dfxtp_2
X_3987_ _5682_/A0 _4528_/A _3994_/S VGND VGND VPWR VPWR _7347_/D sky130_fd_sc_hd__mux2_2
XFILLER_10_318 VGND VGND VPWR VPWR sky130_fd_sc_hd__decap_3
XFILLER_22_189 VGND VGND VPWR VPWR sky130_fd_sc_hd__decap_3
XFILLER_108_228 VGND VGND VPWR VPWR sky130_fd_sc_hd__decap_3
X_5657_ _5657_/A _5657_/B _5657_/C _5657_/D VGND VGND VPWR VPWR _5664_/C sky130_fd_sc_hd__nor4_2
XTAP_TAPCELL_ROW_79_1145 VGND VPWR sky130_fd_sc_hd__tapvpwrvgnd_1
X_4608_ _4938_/A _4608_/B VGND VGND VPWR VPWR _4608_/Y sky130_fd_sc_hd__nor2_2
XFILLER_2_517 VGND VGND VPWR VPWR sky130_fd_sc_hd__decap_3
XFILLER_2_539 VGND VGND VPWR VPWR sky130_fd_sc_hd__decap_3
X_7327_ _7364_/CLK _7327_/D _6607_/Y VGND VGND VPWR VPWR _7327_/Q sky130_fd_sc_hd__dfrtp_2
XFILLER_89_134 VGND VGND VPWR VPWR sky130_fd_sc_hd__decap_3
X_7258_ _7280_/CLK _7258_/D _6538_/Y VGND VGND VPWR VPWR _7258_/Q sky130_fd_sc_hd__dfrtp_2
XFILLER_77_49 VGND VGND VPWR VPWR sky130_fd_sc_hd__decap_3
X_7189_ _7382_/CLK _7189_/D _6469_/Y VGND VGND VPWR VPWR _7189_/Q sky130_fd_sc_hd__dfrtp_2
Xhold1030 _7313_/Q VGND VGND VPWR VPWR _4532_/A0 sky130_fd_sc_hd__dlygate4sd3_1
Xhold1041 _7224_/Q VGND VGND VPWR VPWR _5209_/A sky130_fd_sc_hd__dlygate4sd3_1
XFILLER_18_429 VGND VGND VPWR VPWR sky130_fd_sc_hd__decap_3
XFILLER_45_215 VGND VGND VPWR VPWR sky130_fd_sc_hd__decap_3
XFILLER_73_513 VGND VGND VPWR VPWR sky130_fd_sc_hd__decap_3
XFILLER_85_373 VGND VGND VPWR VPWR sky130_fd_sc_hd__decap_3
XFILLER_93_37 VGND VGND VPWR VPWR sky130_fd_sc_hd__decap_3
Xhold1052 _7246_/Q VGND VGND VPWR VPWR _5163_/A sky130_fd_sc_hd__dlygate4sd3_1
Xhold1063 _7211_/Q VGND VGND VPWR VPWR _5239_/A1 sky130_fd_sc_hd__dlygate4sd3_1
Xhold1074 _7222_/Q VGND VGND VPWR VPWR _5213_/A sky130_fd_sc_hd__dlygate4sd3_1
Xhold1085 _7288_/Q VGND VGND VPWR VPWR _4585_/A sky130_fd_sc_hd__dlygate4sd3_1
Xhold1096 _7283_/Q VGND VGND VPWR VPWR _4595_/A sky130_fd_sc_hd__dlygate4sd3_1
XFILLER_14_613 VGND VGND VPWR VPWR sky130_fd_sc_hd__decap_3
Xclkbuf_3_6__f_clk clkbuf_0_clk/X VGND VGND VPWR VPWR clkbuf_3_6__f_clk/X sky130_fd_sc_hd__clkbuf_16
XFILLER_53_281 VGND VGND VPWR VPWR sky130_fd_sc_hd__fill_1
XFILLER_41_443 VGND VGND VPWR VPWR sky130_fd_sc_hd__decap_3
XFILLER_41_498 VGND VGND VPWR VPWR sky130_fd_sc_hd__decap_3
XFILLER_9_149 VGND VGND VPWR VPWR sky130_fd_sc_hd__decap_3
XFILLER_9_127 VGND VGND VPWR VPWR sky130_fd_sc_hd__decap_3
XFILLER_42_85 VGND VGND VPWR VPWR sky130_fd_sc_hd__fill_1
XTAP_TAPCELL_ROW_11_357 VGND VPWR sky130_fd_sc_hd__tapvpwrvgnd_1
XFILLER_5_333 VGND VGND VPWR VPWR sky130_fd_sc_hd__decap_3
XFILLER_5_399 VGND VGND VPWR VPWR sky130_fd_sc_hd__fill_2
XFILLER_1_550 VGND VGND VPWR VPWR sky130_fd_sc_hd__decap_3
XFILLER_1_561 VGND VGND VPWR VPWR sky130_fd_sc_hd__decap_3
XFILLER_3_57 VGND VGND VPWR VPWR sky130_fd_sc_hd__fill_2
XFILLER_49_510 VGND VGND VPWR VPWR sky130_fd_sc_hd__decap_3
XFILLER_95_148 VGND VGND VPWR VPWR sky130_fd_sc_hd__fill_1
XFILLER_76_340 VGND VGND VPWR VPWR sky130_fd_sc_hd__decap_3
XFILLER_95_159 VGND VGND VPWR VPWR sky130_fd_sc_hd__decap_3
XFILLER_36_215 VGND VGND VPWR VPWR sky130_fd_sc_hd__decap_3
XFILLER_76_395 VGND VGND VPWR VPWR sky130_fd_sc_hd__decap_3
XFILLER_36_259 VGND VGND VPWR VPWR sky130_fd_sc_hd__decap_3
XFILLER_64_568 VGND VGND VPWR VPWR sky130_fd_sc_hd__fill_1
XFILLER_91_365 VGND VGND VPWR VPWR sky130_fd_sc_hd__decap_3
XTAP_TAPCELL_ROW_47_777 VGND VPWR sky130_fd_sc_hd__tapvpwrvgnd_1
XTAP_TAPCELL_ROW_19_457 VGND VPWR sky130_fd_sc_hd__tapvpwrvgnd_1
XFILLER_32_432 VGND VGND VPWR VPWR sky130_fd_sc_hd__fill_1
X_4890_ _5101_/A _4890_/B VGND VGND VPWR VPWR _4890_/Y sky130_fd_sc_hd__nor2_2
X_3910_ _6916_/Q _3912_/A2 _3913_/A2 _6780_/Q VGND VGND VPWR VPWR _3910_/X sky130_fd_sc_hd__a22o_2
XFILLER_20_616 VGND VGND VPWR VPWR sky130_fd_sc_hd__decap_3
X_3841_ _6845_/Q _3886_/A2 _3887_/A2 _6830_/Q _3840_/X VGND VGND VPWR VPWR _3841_/X
+ sky130_fd_sc_hd__a221o_2
X_6560_ _6592_/A VGND VGND VPWR VPWR _6560_/Y sky130_fd_sc_hd__inv_2
X_3772_ _6854_/Q _3913_/B1 _3912_/B1 _6902_/Q _3771_/X VGND VGND VPWR VPWR _3772_/X
+ sky130_fd_sc_hd__a221o_2
X_6491_ _6677_/A VGND VGND VPWR VPWR _6491_/Y sky130_fd_sc_hd__inv_2
XFILLER_105_209 VGND VGND VPWR VPWR sky130_fd_sc_hd__decap_3
X_5373_ _5373_/A0 _4792_/X _5392_/S VGND VGND VPWR VPWR _7146_/D sky130_fd_sc_hd__mux2_2
X_7112_ _7374_/CLK _7112_/D _6392_/Y VGND VGND VPWR VPWR _7112_/Q sky130_fd_sc_hd__dfrtp_2
Xoutput468 _5656_/C VGND VGND VPWR VPWR alu_result_out[19] sky130_fd_sc_hd__clkdlybuf4s25_1
X_4324_ _7039_/Q _4244_/B _4354_/B1 _7386_/Q VGND VGND VPWR VPWR _4324_/X sky130_fd_sc_hd__a22o_2
X_7043_ _7392_/CLK _7043_/D _6323_/Y VGND VGND VPWR VPWR _7043_/Q sky130_fd_sc_hd__dfrtp_2
Xoutput479 _5653_/Y VGND VGND VPWR VPWR alu_result_out[29] sky130_fd_sc_hd__clkdlybuf4s25_1
XTAP_TAPCELL_ROW_74_1086 VGND VPWR sky130_fd_sc_hd__tapvpwrvgnd_1
XFILLER_86_137 VGND VGND VPWR VPWR sky130_fd_sc_hd__decap_3
XFILLER_87_638 VGND VGND VPWR VPWR sky130_fd_sc_hd__decap_3
X_4255_ _4251_/X _4254_/X _4327_/A VGND VGND VPWR VPWR _4256_/C sky130_fd_sc_hd__o21ai_2
X_4186_ _4186_/A _4636_/B VGND VGND VPWR VPWR _4186_/Y sky130_fd_sc_hd__xnor2_2
XFILLER_55_535 VGND VGND VPWR VPWR sky130_fd_sc_hd__decap_3
XFILLER_27_259 VGND VGND VPWR VPWR sky130_fd_sc_hd__decap_3
XFILLER_82_321 VGND VGND VPWR VPWR sky130_fd_sc_hd__decap_3
XFILLER_94_181 VGND VGND VPWR VPWR sky130_fd_sc_hd__decap_3
XFILLER_42_218 VGND VGND VPWR VPWR sky130_fd_sc_hd__decap_3
XFILLER_55_579 VGND VGND VPWR VPWR sky130_fd_sc_hd__fill_1
XFILLER_63_29 VGND VGND VPWR VPWR sky130_fd_sc_hd__decap_3
XFILLER_82_365 VGND VGND VPWR VPWR sky130_fd_sc_hd__fill_1
XFILLER_23_421 VGND VGND VPWR VPWR sky130_fd_sc_hd__decap_3
XFILLER_35_270 VGND VGND VPWR VPWR sky130_fd_sc_hd__decap_3
XFILLER_35_281 VGND VGND VPWR VPWR sky130_fd_sc_hd__fill_2
XFILLER_23_443 VGND VGND VPWR VPWR sky130_fd_sc_hd__fill_2
X_6827_ _6958_/CLK _6827_/D VGND VGND VPWR VPWR _6827_/Q sky130_fd_sc_hd__dfxtp_2
XFILLER_11_638 VGND VGND VPWR VPWR sky130_fd_sc_hd__decap_3
XFILLER_10_148 VGND VGND VPWR VPWR sky130_fd_sc_hd__fill_1
XFILLER_7_609 VGND VGND VPWR VPWR sky130_fd_sc_hd__decap_3
X_6758_ _6966_/CLK _6758_/D VGND VGND VPWR VPWR _6758_/Q sky130_fd_sc_hd__dfxtp_2
X_6689_ clkload4/A _6689_/D VGND VGND VPWR VPWR _6689_/Q sky130_fd_sc_hd__dfxtp_2
XFILLER_12_55 VGND VGND VPWR VPWR sky130_fd_sc_hd__decap_3
XFILLER_12_99 VGND VGND VPWR VPWR sky130_fd_sc_hd__fill_2
XFILLER_104_231 VGND VGND VPWR VPWR sky130_fd_sc_hd__decap_3
XFILLER_104_253 VGND VGND VPWR VPWR sky130_fd_sc_hd__fill_1
XFILLER_2_358 VGND VGND VPWR VPWR sky130_fd_sc_hd__decap_3
XFILLER_104_297 VGND VGND VPWR VPWR sky130_fd_sc_hd__fill_2
XFILLER_77_137 VGND VGND VPWR VPWR sky130_fd_sc_hd__decap_3
XFILLER_78_638 VGND VGND VPWR VPWR sky130_fd_sc_hd__decap_3
XFILLER_18_215 VGND VGND VPWR VPWR sky130_fd_sc_hd__decap_3
XFILLER_46_502 VGND VGND VPWR VPWR sky130_fd_sc_hd__fill_2
XFILLER_46_524 VGND VGND VPWR VPWR sky130_fd_sc_hd__fill_1
XFILLER_73_332 VGND VGND VPWR VPWR sky130_fd_sc_hd__decap_3
XFILLER_73_343 VGND VGND VPWR VPWR sky130_fd_sc_hd__decap_3
XFILLER_33_207 VGND VGND VPWR VPWR sky130_fd_sc_hd__decap_3
XFILLER_61_505 VGND VGND VPWR VPWR sky130_fd_sc_hd__decap_3
XFILLER_73_376 VGND VGND VPWR VPWR sky130_fd_sc_hd__decap_3
XFILLER_14_421 VGND VGND VPWR VPWR sky130_fd_sc_hd__decap_3
XFILLER_26_281 VGND VGND VPWR VPWR sky130_fd_sc_hd__decap_3
XFILLER_61_538 VGND VGND VPWR VPWR sky130_fd_sc_hd__fill_2
XTAP_TAPCELL_ROW_44_736 VGND VPWR sky130_fd_sc_hd__tapvpwrvgnd_1
XTAP_TAPCELL_ROW_16_416 VGND VPWR sky130_fd_sc_hd__tapvpwrvgnd_1
XFILLER_41_284 VGND VGND VPWR VPWR sky130_fd_sc_hd__fill_1
XFILLER_53_84 VGND VGND VPWR VPWR sky130_fd_sc_hd__decap_3
XFILLER_6_631 VGND VGND VPWR VPWR sky130_fd_sc_hd__decap_3
XFILLER_108_570 VGND VGND VPWR VPWR sky130_fd_sc_hd__decap_3
XFILLER_108_581 VGND VGND VPWR VPWR sky130_fd_sc_hd__decap_3
XFILLER_108_592 VGND VGND VPWR VPWR sky130_fd_sc_hd__decap_3
XFILLER_45_6 VGND VGND VPWR VPWR sky130_fd_sc_hd__decap_3
XFILLER_69_638 VGND VGND VPWR VPWR sky130_fd_sc_hd__decap_3
XFILLER_68_159 VGND VGND VPWR VPWR sky130_fd_sc_hd__decap_3
X_4040_ _4608_/B _4040_/B VGND VGND VPWR VPWR _4040_/Y sky130_fd_sc_hd__nor2_2
XFILLER_37_524 VGND VGND VPWR VPWR sky130_fd_sc_hd__decap_3
XFILLER_49_373 VGND VGND VPWR VPWR sky130_fd_sc_hd__decap_3
XFILLER_76_192 VGND VGND VPWR VPWR sky130_fd_sc_hd__decap_3
XFILLER_24_218 VGND VGND VPWR VPWR sky130_fd_sc_hd__decap_3
XFILLER_37_579 VGND VGND VPWR VPWR sky130_fd_sc_hd__decap_3
XFILLER_52_516 VGND VGND VPWR VPWR sky130_fd_sc_hd__decap_3
XFILLER_91_151 VGND VGND VPWR VPWR sky130_fd_sc_hd__decap_3
XFILLER_17_270 VGND VGND VPWR VPWR sky130_fd_sc_hd__fill_1
XFILLER_64_398 VGND VGND VPWR VPWR sky130_fd_sc_hd__decap_3
X_4942_ _6995_/Q _4960_/B _4677_/B _5667_/A VGND VGND VPWR VPWR _4943_/B sky130_fd_sc_hd__o211ai_2
XFILLER_17_292 VGND VGND VPWR VPWR sky130_fd_sc_hd__decap_3
XFILLER_32_251 VGND VGND VPWR VPWR sky130_fd_sc_hd__fill_1
XFILLER_32_284 VGND VGND VPWR VPWR sky130_fd_sc_hd__decap_3
X_6612_ _6612_/A VGND VGND VPWR VPWR _6612_/Y sky130_fd_sc_hd__inv_2
X_4873_ _4764_/B _4111_/B _4845_/A _5101_/A VGND VGND VPWR VPWR _4873_/X sky130_fd_sc_hd__o22a_2
XFILLER_20_435 VGND VGND VPWR VPWR sky130_fd_sc_hd__decap_3
X_3824_ _6965_/Q _3862_/A2 _3824_/B1 _6953_/Q _3823_/X VGND VGND VPWR VPWR _3824_/X
+ sky130_fd_sc_hd__a221o_2
X_6543_ _6680_/A VGND VGND VPWR VPWR _6543_/Y sky130_fd_sc_hd__inv_2
X_3755_ _6934_/Q _3862_/A2 _3912_/B1 _6886_/Q VGND VGND VPWR VPWR _3755_/X sky130_fd_sc_hd__a22o_2
X_6474_ _6541_/A VGND VGND VPWR VPWR _6474_/Y sky130_fd_sc_hd__inv_2
XTAP_TAPCELL_ROW_76_1104 VGND VPWR sky130_fd_sc_hd__tapvpwrvgnd_1
XFILLER_106_518 VGND VGND VPWR VPWR sky130_fd_sc_hd__decap_3
X_5425_ _5425_/A0 _3993_/X _5429_/S VGND VGND VPWR VPWR _7121_/D sky130_fd_sc_hd__mux2_2
XPHY_EDGE_ROW_12_Right_12 VGND VGND VPWR VPWR sky130_fd_sc_hd__decap_3
XFILLER_58_29 VGND VGND VPWR VPWR sky130_fd_sc_hd__fill_1
XFILLER_87_402 VGND VGND VPWR VPWR sky130_fd_sc_hd__decap_3
X_5356_ _5356_/A0 _3993_/X _7412_/A VGND VGND VPWR VPWR _7153_/D sky130_fd_sc_hd__mux2_2
XFILLER_101_212 VGND VGND VPWR VPWR sky130_fd_sc_hd__decap_3
XFILLER_87_446 VGND VGND VPWR VPWR sky130_fd_sc_hd__fill_2
X_4307_ _7224_/Q _4307_/A2 _4534_/S _7037_/Q VGND VGND VPWR VPWR _4307_/X sky130_fd_sc_hd__a22o_2
XFILLER_99_273 VGND VGND VPWR VPWR sky130_fd_sc_hd__decap_3
XFILLER_101_234 VGND VGND VPWR VPWR sky130_fd_sc_hd__decap_3
XFILLER_59_159 VGND VGND VPWR VPWR sky130_fd_sc_hd__fill_2
X_7026_ _7372_/CLK _7026_/D _6306_/Y VGND VGND VPWR VPWR _7026_/Q sky130_fd_sc_hd__dfrtp_2
X_4238_ _7067_/Q _3558_/B _3429_/X _4237_/X VGND VGND VPWR VPWR _4629_/B sky130_fd_sc_hd__o211ai_2
XFILLER_101_278 VGND VGND VPWR VPWR sky130_fd_sc_hd__fill_2
XFILLER_74_107 VGND VGND VPWR VPWR sky130_fd_sc_hd__fill_2
XFILLER_55_343 VGND VGND VPWR VPWR sky130_fd_sc_hd__decap_3
XFILLER_67_181 VGND VGND VPWR VPWR sky130_fd_sc_hd__decap_3
X_4169_ _4165_/X _4168_/X _4425_/A VGND VGND VPWR VPWR _4202_/A sky130_fd_sc_hd__o21a_2
XTAP_TAPCELL_ROW_87_1233 VGND VPWR sky130_fd_sc_hd__tapvpwrvgnd_1
XFILLER_28_568 VGND VGND VPWR VPWR sky130_fd_sc_hd__decap_3
XFILLER_43_505 VGND VGND VPWR VPWR sky130_fd_sc_hd__fill_2
XPHY_EDGE_ROW_21_Right_21 VGND VGND VPWR VPWR sky130_fd_sc_hd__decap_3
XFILLER_55_387 VGND VGND VPWR VPWR sky130_fd_sc_hd__decap_3
XFILLER_70_368 VGND VGND VPWR VPWR sky130_fd_sc_hd__decap_3
XFILLER_90_27 VGND VGND VPWR VPWR sky130_fd_sc_hd__fill_1
XTAP_TAPCELL_ROW_41_706 VGND VPWR sky130_fd_sc_hd__tapvpwrvgnd_1
XFILLER_23_262 VGND VGND VPWR VPWR sky130_fd_sc_hd__decap_3
XTAP_TAPCELL_ROW_98_1362 VGND VPWR sky130_fd_sc_hd__tapvpwrvgnd_1
XTAP_TAPCELL_ROW_21_474 VGND VPWR sky130_fd_sc_hd__tapvpwrvgnd_1
XPHY_EDGE_ROW_30_Right_30 VGND VGND VPWR VPWR sky130_fd_sc_hd__decap_3
XFILLER_3_612 VGND VGND VPWR VPWR sky130_fd_sc_hd__decap_3
XFILLER_3_623 VGND VGND VPWR VPWR sky130_fd_sc_hd__decap_3
XFILLER_105_540 VGND VGND VPWR VPWR sky130_fd_sc_hd__fill_1
XFILLER_2_144 VGND VGND VPWR VPWR sky130_fd_sc_hd__decap_3
XFILLER_2_177 VGND VGND VPWR VPWR sky130_fd_sc_hd__decap_3
XFILLER_66_619 VGND VGND VPWR VPWR sky130_fd_sc_hd__decap_3
XFILLER_0_14 VGND VGND VPWR VPWR sky130_fd_sc_hd__decap_3
XFILLER_58_181 VGND VGND VPWR VPWR sky130_fd_sc_hd__decap_3
XFILLER_93_449 VGND VGND VPWR VPWR sky130_fd_sc_hd__fill_2
XFILLER_46_365 VGND VGND VPWR VPWR sky130_fd_sc_hd__decap_3
XTAP_TAPCELL_ROW_29_563 VGND VPWR sky130_fd_sc_hd__tapvpwrvgnd_1
XFILLER_34_527 VGND VGND VPWR VPWR sky130_fd_sc_hd__fill_2
XFILLER_61_313 VGND VGND VPWR VPWR sky130_fd_sc_hd__decap_3
XFILLER_73_184 VGND VGND VPWR VPWR sky130_fd_sc_hd__fill_1
XFILLER_73_195 VGND VGND VPWR VPWR sky130_fd_sc_hd__decap_3
XTAP_TAPCELL_ROW_57_894 VGND VPWR sky130_fd_sc_hd__tapvpwrvgnd_1
XPHY_EDGE_ROW_14_Left_123 VGND VGND VPWR VPWR sky130_fd_sc_hd__decap_3
XFILLER_64_94 VGND VGND VPWR VPWR sky130_fd_sc_hd__fill_1
XFILLER_14_251 VGND VGND VPWR VPWR sky130_fd_sc_hd__fill_1
XFILLER_14_295 VGND VGND VPWR VPWR sky130_fd_sc_hd__decap_3
X_3540_ _3502_/A _3502_/B _3485_/C VGND VGND VPWR VPWR _3540_/X sky130_fd_sc_hd__o21a_2
Xhold907 _6690_/Q VGND VGND VPWR VPWR hold907/X sky130_fd_sc_hd__dlygate4sd3_1
Xhold918 _6706_/Q VGND VGND VPWR VPWR hold918/X sky130_fd_sc_hd__dlygate4sd3_1
Xhold929 _6697_/Q VGND VGND VPWR VPWR hold929/X sky130_fd_sc_hd__dlygate4sd3_1
X_3471_ _3545_/A _3545_/B VGND VGND VPWR VPWR _3505_/A sky130_fd_sc_hd__and2b_2
XPHY_EDGE_ROW_23_Left_132 VGND VGND VPWR VPWR sky130_fd_sc_hd__decap_3
XFILLER_69_402 VGND VGND VPWR VPWR sky130_fd_sc_hd__decap_3
XFILLER_89_80 VGND VGND VPWR VPWR sky130_fd_sc_hd__decap_3
XFILLER_96_210 VGND VGND VPWR VPWR sky130_fd_sc_hd__decap_3
X_5072_ _5072_/A _5072_/B _5072_/C VGND VGND VPWR VPWR _5075_/B sky130_fd_sc_hd__and3_2
XTAP_TAPCELL_ROW_71_1056 VGND VPWR sky130_fd_sc_hd__tapvpwrvgnd_1
XFILLER_56_129 VGND VGND VPWR VPWR sky130_fd_sc_hd__decap_3
XFILLER_84_405 VGND VGND VPWR VPWR sky130_fd_sc_hd__decap_3
XFILLER_84_427 VGND VGND VPWR VPWR sky130_fd_sc_hd__decap_3
XFILLER_49_181 VGND VGND VPWR VPWR sky130_fd_sc_hd__decap_3
XFILLER_65_641 VGND VGND VPWR VPWR sky130_fd_sc_hd__decap_3
XFILLER_25_505 VGND VGND VPWR VPWR sky130_fd_sc_hd__decap_3
XFILLER_37_343 VGND VGND VPWR VPWR sky130_fd_sc_hd__decap_3
XFILLER_37_365 VGND VGND VPWR VPWR sky130_fd_sc_hd__decap_3
XFILLER_64_151 VGND VGND VPWR VPWR sky130_fd_sc_hd__decap_3
XPHY_EDGE_ROW_32_Left_141 VGND VGND VPWR VPWR sky130_fd_sc_hd__decap_3
XFILLER_64_184 VGND VGND VPWR VPWR sky130_fd_sc_hd__decap_3
XFILLER_92_471 VGND VGND VPWR VPWR sky130_fd_sc_hd__decap_3
XFILLER_92_493 VGND VGND VPWR VPWR sky130_fd_sc_hd__fill_1
XFILLER_52_346 VGND VGND VPWR VPWR sky130_fd_sc_hd__decap_3
XFILLER_52_368 VGND VGND VPWR VPWR sky130_fd_sc_hd__decap_3
XFILLER_100_26 VGND VGND VPWR VPWR sky130_fd_sc_hd__fill_2
X_4925_ _4764_/B _4158_/A _4920_/A _5101_/A _4924_/X VGND VGND VPWR VPWR _4925_/X
+ sky130_fd_sc_hd__o221a_2
XTAP_TAPCELL_ROW_82_1174 VGND VPWR sky130_fd_sc_hd__tapvpwrvgnd_1
X_3807_ _6703_/Q _3893_/B1 _3852_/B1 _6881_/Q VGND VGND VPWR VPWR _3807_/X sky130_fd_sc_hd__a22o_2
XFILLER_20_276 VGND VGND VPWR VPWR sky130_fd_sc_hd__fill_1
XFILLER_20_287 VGND VGND VPWR VPWR sky130_fd_sc_hd__decap_3
XFILLER_20_298 VGND VGND VPWR VPWR sky130_fd_sc_hd__decap_3
X_6526_ _6619_/A VGND VGND VPWR VPWR _6526_/Y sky130_fd_sc_hd__inv_2
X_4787_ _4787_/A _4787_/B VGND VGND VPWR VPWR _4787_/Y sky130_fd_sc_hd__xnor2_2
X_3738_ _6740_/Q _3889_/A2 _3911_/A2 _6734_/Q _3737_/X VGND VGND VPWR VPWR _3738_/X
+ sky130_fd_sc_hd__a221o_2
XPHY_EDGE_ROW_41_Left_150 VGND VGND VPWR VPWR sky130_fd_sc_hd__decap_3
XFILLER_69_39 VGND VGND VPWR VPWR sky130_fd_sc_hd__fill_1
X_6457_ _6650_/A VGND VGND VPWR VPWR _6457_/Y sky130_fd_sc_hd__inv_2
X_3669_ _6807_/Q _3824_/B1 _3823_/A2 _6717_/Q _3668_/X VGND VGND VPWR VPWR _3669_/X
+ sky130_fd_sc_hd__a221o_2
X_6388_ _6644_/A VGND VGND VPWR VPWR _6388_/Y sky130_fd_sc_hd__inv_2
XFILLER_87_221 VGND VGND VPWR VPWR sky130_fd_sc_hd__decap_3
XFILLER_102_587 VGND VGND VPWR VPWR sky130_fd_sc_hd__fill_1
XFILLER_48_619 VGND VGND VPWR VPWR sky130_fd_sc_hd__decap_3
XFILLER_87_276 VGND VGND VPWR VPWR sky130_fd_sc_hd__decap_3
XFILLER_18_21 VGND VGND VPWR VPWR sky130_fd_sc_hd__decap_3
XFILLER_56_630 VGND VGND VPWR VPWR sky130_fd_sc_hd__decap_3
XFILLER_68_490 VGND VGND VPWR VPWR sky130_fd_sc_hd__fill_2
XFILLER_75_438 VGND VGND VPWR VPWR sky130_fd_sc_hd__fill_2
XFILLER_75_449 VGND VGND VPWR VPWR sky130_fd_sc_hd__decap_3
X_7009_ _7083_/CLK _7009_/D _6289_/Y VGND VGND VPWR VPWR _7009_/Q sky130_fd_sc_hd__dfrtp_2
XFILLER_18_54 VGND VGND VPWR VPWR sky130_fd_sc_hd__decap_3
XFILLER_18_65 VGND VGND VPWR VPWR sky130_fd_sc_hd__decap_3
XFILLER_28_354 VGND VGND VPWR VPWR sky130_fd_sc_hd__decap_3
XFILLER_28_365 VGND VGND VPWR VPWR sky130_fd_sc_hd__fill_1
XFILLER_55_140 VGND VGND VPWR VPWR sky130_fd_sc_hd__decap_3
XFILLER_90_408 VGND VGND VPWR VPWR sky130_fd_sc_hd__decap_3
XFILLER_55_162 VGND VGND VPWR VPWR sky130_fd_sc_hd__decap_3
XFILLER_55_184 VGND VGND VPWR VPWR sky130_fd_sc_hd__decap_3
XFILLER_71_644 VGND VGND VPWR VPWR sky130_fd_sc_hd__decap_3
XFILLER_70_121 VGND VGND VPWR VPWR sky130_fd_sc_hd__decap_3
XTAP_TAPCELL_ROW_54_853 VGND VPWR sky130_fd_sc_hd__tapvpwrvgnd_1
XTAP_TAPCELL_ROW_26_533 VGND VPWR sky130_fd_sc_hd__tapvpwrvgnd_1
XFILLER_24_571 VGND VGND VPWR VPWR sky130_fd_sc_hd__decap_3
XFILLER_70_165 VGND VGND VPWR VPWR sky130_fd_sc_hd__decap_3
XFILLER_70_187 VGND VGND VPWR VPWR sky130_fd_sc_hd__fill_1
XFILLER_11_254 VGND VGND VPWR VPWR sky130_fd_sc_hd__decap_3
XFILLER_11_287 VGND VGND VPWR VPWR sky130_fd_sc_hd__decap_3
XFILLER_7_225 VGND VGND VPWR VPWR sky130_fd_sc_hd__decap_3
XFILLER_50_74 VGND VGND VPWR VPWR sky130_fd_sc_hd__fill_2
XFILLER_50_85 VGND VGND VPWR VPWR sky130_fd_sc_hd__decap_3
XFILLER_7_258 VGND VGND VPWR VPWR sky130_fd_sc_hd__decap_3
XFILLER_3_420 VGND VGND VPWR VPWR sky130_fd_sc_hd__decap_3
XFILLER_93_213 VGND VGND VPWR VPWR sky130_fd_sc_hd__fill_1
XFILLER_47_641 VGND VGND VPWR VPWR sky130_fd_sc_hd__decap_3
XFILLER_66_438 VGND VGND VPWR VPWR sky130_fd_sc_hd__decap_3
XFILLER_78_298 VGND VGND VPWR VPWR sky130_fd_sc_hd__decap_3
XFILLER_93_268 VGND VGND VPWR VPWR sky130_fd_sc_hd__decap_3
XFILLER_93_279 VGND VGND VPWR VPWR sky130_fd_sc_hd__fill_1
XFILLER_34_302 VGND VGND VPWR VPWR sky130_fd_sc_hd__decap_3
XFILLER_46_162 VGND VGND VPWR VPWR sky130_fd_sc_hd__decap_3
XFILLER_62_633 VGND VGND VPWR VPWR sky130_fd_sc_hd__decap_3
XFILLER_22_508 VGND VGND VPWR VPWR sky130_fd_sc_hd__fill_2
XFILLER_34_368 VGND VGND VPWR VPWR sky130_fd_sc_hd__decap_3
XFILLER_61_121 VGND VGND VPWR VPWR sky130_fd_sc_hd__decap_3
XTAP_TAPCELL_ROW_105_1439 VGND VPWR sky130_fd_sc_hd__tapvpwrvgnd_1
XFILLER_15_582 VGND VGND VPWR VPWR sky130_fd_sc_hd__decap_3
XFILLER_30_530 VGND VGND VPWR VPWR sky130_fd_sc_hd__fill_2
X_5690_ _7351_/Q _5690_/A1 _5708_/S VGND VGND VPWR VPWR _6695_/D sky130_fd_sc_hd__mux2_2
X_4710_ _7004_/Q _4801_/A VGND VGND VPWR VPWR _4775_/A sky130_fd_sc_hd__and2_2
X_4641_ _4920_/A _4379_/B _4640_/Y _4158_/A VGND VGND VPWR VPWR _4903_/B sky130_fd_sc_hd__o31a_2
XFILLER_30_585 VGND VGND VPWR VPWR sky130_fd_sc_hd__decap_3
X_7360_ _7364_/CLK _7360_/D _6640_/Y VGND VGND VPWR VPWR _7360_/Q sky130_fd_sc_hd__dfrtp_2
X_7291_ _7356_/CLK _7291_/D _6571_/Y VGND VGND VPWR VPWR _7291_/Q sky130_fd_sc_hd__dfrtp_2
Xhold704 _6974_/Q VGND VGND VPWR VPWR _6974_/D sky130_fd_sc_hd__dlygate4sd3_1
Xhold715 _6767_/Q VGND VGND VPWR VPWR _6767_/D sky130_fd_sc_hd__dlygate4sd3_1
Xhold726 _6957_/Q VGND VGND VPWR VPWR _6957_/D sky130_fd_sc_hd__dlygate4sd3_1
Xhold737 _6816_/Q VGND VGND VPWR VPWR _6816_/D sky130_fd_sc_hd__dlygate4sd3_1
X_6311_ _6592_/A VGND VGND VPWR VPWR _6311_/Y sky130_fd_sc_hd__inv_2
X_3523_ _3505_/A _3458_/Y _3505_/B _3506_/Y _3508_/A VGND VGND VPWR VPWR _3620_/A
+ sky130_fd_sc_hd__o311a_4
Xhold748 _6724_/Q VGND VGND VPWR VPWR _6724_/D sky130_fd_sc_hd__dlygate4sd3_1
Xhold759 _6854_/Q VGND VGND VPWR VPWR _6854_/D sky130_fd_sc_hd__dlygate4sd3_1
X_3454_ _7186_/Q _3989_/S _4495_/S _7031_/Q _3453_/X VGND VGND VPWR VPWR _3454_/X
+ sky130_fd_sc_hd__a221o_2
XFILLER_69_221 VGND VGND VPWR VPWR sky130_fd_sc_hd__decap_3
X_3385_ _6983_/Q _5130_/A VGND VGND VPWR VPWR _3385_/Y sky130_fd_sc_hd__nor2_2
XFILLER_97_552 VGND VGND VPWR VPWR sky130_fd_sc_hd__decap_3
XFILLER_57_405 VGND VGND VPWR VPWR sky130_fd_sc_hd__decap_3
XFILLER_69_287 VGND VGND VPWR VPWR sky130_fd_sc_hd__decap_3
X_5124_ _3746_/B _3900_/Y _4677_/B VGND VGND VPWR VPWR _5125_/B sky130_fd_sc_hd__a21o_2
XFILLER_38_630 VGND VGND VPWR VPWR sky130_fd_sc_hd__decap_3
XFILLER_57_449 VGND VGND VPWR VPWR sky130_fd_sc_hd__fill_2
X_5055_ _4811_/C _5049_/X _5053_/Y _5054_/Y _4369_/A VGND VGND VPWR VPWR _5055_/X
+ sky130_fd_sc_hd__a221o_2
XFILLER_53_611 VGND VGND VPWR VPWR sky130_fd_sc_hd__decap_3
XFILLER_65_493 VGND VGND VPWR VPWR sky130_fd_sc_hd__decap_3
XTAP_TAPCELL_ROW_84_1203 VGND VPWR sky130_fd_sc_hd__tapvpwrvgnd_1
XFILLER_53_644 VGND VGND VPWR VPWR sky130_fd_sc_hd__decap_3
XFILLER_25_368 VGND VGND VPWR VPWR sky130_fd_sc_hd__decap_3
XFILLER_80_474 VGND VGND VPWR VPWR sky130_fd_sc_hd__fill_2
XTAP_TAPCELL_ROW_51_823 VGND VPWR sky130_fd_sc_hd__tapvpwrvgnd_1
XTAP_TAPCELL_ROW_23_503 VGND VPWR sky130_fd_sc_hd__tapvpwrvgnd_1
XFILLER_33_390 VGND VGND VPWR VPWR sky130_fd_sc_hd__fill_2
XFILLER_40_327 VGND VGND VPWR VPWR sky130_fd_sc_hd__fill_1
XFILLER_80_496 VGND VGND VPWR VPWR sky130_fd_sc_hd__decap_3
X_4908_ _4908_/A _4908_/B VGND VGND VPWR VPWR _4909_/C sky130_fd_sc_hd__nor2_2
XFILLER_21_596 VGND VGND VPWR VPWR sky130_fd_sc_hd__decap_3
X_4839_ _4916_/A _4916_/B _4634_/Y VGND VGND VPWR VPWR _4903_/C sky130_fd_sc_hd__a21o_2
XTAP_TAPCELL_ROW_31_591 VGND VPWR sky130_fd_sc_hd__tapvpwrvgnd_1
XFILLER_20_11 VGND VGND VPWR VPWR sky130_fd_sc_hd__fill_1
X_6509_ _6609_/A VGND VGND VPWR VPWR _6509_/Y sky130_fd_sc_hd__inv_2
XTAP_TAPCELL_ROW_95_1332 VGND VPWR sky130_fd_sc_hd__tapvpwrvgnd_1
XFILLER_106_134 VGND VGND VPWR VPWR sky130_fd_sc_hd__fill_1
XFILLER_20_44 VGND VGND VPWR VPWR sky130_fd_sc_hd__fill_2
XFILLER_20_66 VGND VGND VPWR VPWR sky130_fd_sc_hd__fill_1
XFILLER_106_167 VGND VGND VPWR VPWR sky130_fd_sc_hd__decap_3
XFILLER_20_88 VGND VGND VPWR VPWR sky130_fd_sc_hd__decap_3
XFILLER_102_373 VGND VGND VPWR VPWR sky130_fd_sc_hd__decap_3
XFILLER_29_53 VGND VGND VPWR VPWR sky130_fd_sc_hd__decap_3
XFILLER_48_427 VGND VGND VPWR VPWR sky130_fd_sc_hd__decap_3
XFILLER_75_202 VGND VGND VPWR VPWR sky130_fd_sc_hd__decap_3
XFILLER_88_585 VGND VGND VPWR VPWR sky130_fd_sc_hd__decap_3
XTAP_TAPCELL_ROW_59_912 VGND VPWR sky130_fd_sc_hd__tapvpwrvgnd_1
XFILLER_102_395 VGND VGND VPWR VPWR sky130_fd_sc_hd__decap_3
XFILLER_29_86 VGND VGND VPWR VPWR sky130_fd_sc_hd__decap_3
XFILLER_75_235 VGND VGND VPWR VPWR sky130_fd_sc_hd__decap_3
XFILLER_29_641 VGND VGND VPWR VPWR sky130_fd_sc_hd__decap_3
XFILLER_75_268 VGND VGND VPWR VPWR sky130_fd_sc_hd__fill_1
XFILLER_44_622 VGND VGND VPWR VPWR sky130_fd_sc_hd__decap_3
XFILLER_56_471 VGND VGND VPWR VPWR sky130_fd_sc_hd__decap_3
Xplace408 _4285_/B1 VGND VGND VPWR VPWR _4346_/B1 sky130_fd_sc_hd__buf_2
Xplace419 _4414_/B1 VGND VGND VPWR VPWR _3956_/S sky130_fd_sc_hd__buf_2
XTAP_TAPCELL_ROW_3_272 VGND VPWR sky130_fd_sc_hd__tapvpwrvgnd_1
XTAP_TAPCELL_ROW_39_680 VGND VPWR sky130_fd_sc_hd__tapvpwrvgnd_1
XFILLER_16_335 VGND VGND VPWR VPWR sky130_fd_sc_hd__decap_3
XFILLER_28_195 VGND VGND VPWR VPWR sky130_fd_sc_hd__fill_1
XFILLER_83_290 VGND VGND VPWR VPWR sky130_fd_sc_hd__decap_3
XFILLER_16_368 VGND VGND VPWR VPWR sky130_fd_sc_hd__decap_3
XFILLER_71_485 VGND VGND VPWR VPWR sky130_fd_sc_hd__decap_3
XFILLER_12_552 VGND VGND VPWR VPWR sky130_fd_sc_hd__decap_3
XFILLER_12_585 VGND VGND VPWR VPWR sky130_fd_sc_hd__decap_3
XFILLER_6_24 VGND VGND VPWR VPWR sky130_fd_sc_hd__decap_3
XFILLER_8_578 VGND VGND VPWR VPWR sky130_fd_sc_hd__decap_3
XFILLER_8_589 VGND VGND VPWR VPWR sky130_fd_sc_hd__decap_3
XANTENNA_6 _7362_/Q VGND VGND VPWR VPWR sky130_fd_sc_hd__diode_2
XFILLER_3_294 VGND VGND VPWR VPWR sky130_fd_sc_hd__decap_3
XFILLER_39_405 VGND VGND VPWR VPWR sky130_fd_sc_hd__decap_3
XFILLER_39_416 VGND VGND VPWR VPWR sky130_fd_sc_hd__decap_3
XFILLER_66_235 VGND VGND VPWR VPWR sky130_fd_sc_hd__decap_3
XFILLER_86_81 VGND VGND VPWR VPWR sky130_fd_sc_hd__decap_3
XFILLER_19_140 VGND VGND VPWR VPWR sky130_fd_sc_hd__decap_3
XFILLER_54_419 VGND VGND VPWR VPWR sky130_fd_sc_hd__fill_1
XFILLER_94_566 VGND VGND VPWR VPWR sky130_fd_sc_hd__decap_3
XFILLER_47_460 VGND VGND VPWR VPWR sky130_fd_sc_hd__fill_2
XFILLER_47_471 VGND VGND VPWR VPWR sky130_fd_sc_hd__decap_3
XFILLER_81_205 VGND VGND VPWR VPWR sky130_fd_sc_hd__decap_3
XFILLER_35_644 VGND VGND VPWR VPWR sky130_fd_sc_hd__decap_3
X_6860_ _6968_/CLK _6860_/D VGND VGND VPWR VPWR _6860_/Q sky130_fd_sc_hd__dfxtp_2
XFILLER_22_305 VGND VGND VPWR VPWR sky130_fd_sc_hd__decap_3
XFILLER_34_165 VGND VGND VPWR VPWR sky130_fd_sc_hd__decap_3
XFILLER_50_614 VGND VGND VPWR VPWR sky130_fd_sc_hd__decap_3
X_6791_ _7071_/CLK _6791_/D VGND VGND VPWR VPWR _6791_/Q sky130_fd_sc_hd__dfxtp_2
XFILLER_15_390 VGND VGND VPWR VPWR sky130_fd_sc_hd__fill_2
XFILLER_22_327 VGND VGND VPWR VPWR sky130_fd_sc_hd__fill_2
XFILLER_30_371 VGND VGND VPWR VPWR sky130_fd_sc_hd__fill_1
XFILLER_30_393 VGND VGND VPWR VPWR sky130_fd_sc_hd__fill_2
X_7412_ _7412_/A VGND VGND VPWR VPWR _7412_/X sky130_fd_sc_hd__buf_2
X_4624_ _4624_/A _4624_/B VGND VGND VPWR VPWR _4624_/X sky130_fd_sc_hd__and2_2
XPHY_EDGE_ROW_6_Right_6 VGND VGND VPWR VPWR sky130_fd_sc_hd__decap_3
X_7343_ _7380_/CLK _7343_/D _6623_/Y VGND VGND VPWR VPWR _7343_/Q sky130_fd_sc_hd__dfrtp_2
X_3506_ _3544_/A _3506_/B VGND VGND VPWR VPWR _3506_/Y sky130_fd_sc_hd__nand2_2
XFILLER_104_638 VGND VGND VPWR VPWR sky130_fd_sc_hd__decap_3
X_7274_ _7276_/CLK _7274_/D _6554_/Y VGND VGND VPWR VPWR _7274_/Q sky130_fd_sc_hd__dfrtp_2
X_4486_ _4486_/A0 _7304_/Q _4501_/S VGND VGND VPWR VPWR _7336_/D sky130_fd_sc_hd__mux2_2
XFILLER_103_148 VGND VGND VPWR VPWR sky130_fd_sc_hd__fill_1
XFILLER_106_14 VGND VGND VPWR VPWR sky130_fd_sc_hd__decap_3
XFILLER_89_349 VGND VGND VPWR VPWR sky130_fd_sc_hd__decap_3
Xhold589 _6904_/Q VGND VGND VPWR VPWR _6904_/D sky130_fd_sc_hd__dlygate4sd3_1
XFILLER_103_159 VGND VGND VPWR VPWR sky130_fd_sc_hd__decap_3
XFILLER_106_47 VGND VGND VPWR VPWR sky130_fd_sc_hd__decap_3
XFILLER_85_511 VGND VGND VPWR VPWR sky130_fd_sc_hd__decap_3
X_3368_ _5129_/A _5294_/A _3310_/Y _5670_/A VGND VGND VPWR VPWR _3368_/Y sky130_fd_sc_hd__a211oi_4
XTAP_TAPCELL_ROW_90_1273 VGND VPWR sky130_fd_sc_hd__tapvpwrvgnd_1
XFILLER_85_544 VGND VGND VPWR VPWR sky130_fd_sc_hd__decap_3
Xhold1201 _7175_/Q VGND VGND VPWR VPWR _5310_/A0 sky130_fd_sc_hd__dlygate4sd3_1
Xhold1212 _7293_/Q VGND VGND VPWR VPWR _4575_/A sky130_fd_sc_hd__dlygate4sd3_1
Xhold1223 _7359_/Q VGND VGND VPWR VPWR _3962_/A0 sky130_fd_sc_hd__dlygate4sd3_1
X_5107_ _5156_/S _6985_/D _5105_/X _5106_/X VGND VGND VPWR VPWR _5107_/X sky130_fd_sc_hd__o22a_2
XFILLER_97_393 VGND VGND VPWR VPWR sky130_fd_sc_hd__decap_3
XFILLER_45_408 VGND VGND VPWR VPWR sky130_fd_sc_hd__decap_3
XFILLER_57_246 VGND VGND VPWR VPWR sky130_fd_sc_hd__decap_3
X_3299_ _3327_/B _5129_/B _6981_/Q VGND VGND VPWR VPWR _3328_/A sky130_fd_sc_hd__o21a_2
XFILLER_26_611 VGND VGND VPWR VPWR sky130_fd_sc_hd__decap_3
XFILLER_72_227 VGND VGND VPWR VPWR sky130_fd_sc_hd__decap_3
X_5038_ _5038_/A _5038_/B VGND VGND VPWR VPWR _5038_/X sky130_fd_sc_hd__xor2_2
XTAP_TAPCELL_ROW_0_220 VGND VPWR sky130_fd_sc_hd__tapvpwrvgnd_1
XFILLER_65_290 VGND VGND VPWR VPWR sky130_fd_sc_hd__decap_3
XTAP_TAPCELL_ROW_0_231 VGND VPWR sky130_fd_sc_hd__tapvpwrvgnd_1
XFILLER_13_316 VGND VGND VPWR VPWR sky130_fd_sc_hd__decap_3
XFILLER_25_165 VGND VGND VPWR VPWR sky130_fd_sc_hd__decap_3
XFILLER_53_463 VGND VGND VPWR VPWR sky130_fd_sc_hd__decap_3
XFILLER_53_485 VGND VGND VPWR VPWR sky130_fd_sc_hd__decap_3
XTAP_TAPCELL_ROW_64_970 VGND VPWR sky130_fd_sc_hd__tapvpwrvgnd_1
XTAP_TAPCELL_ROW_36_650 VGND VPWR sky130_fd_sc_hd__tapvpwrvgnd_1
XFILLER_25_187 VGND VGND VPWR VPWR sky130_fd_sc_hd__decap_3
XFILLER_40_113 VGND VGND VPWR VPWR sky130_fd_sc_hd__decap_3
XFILLER_41_647 VGND VGND VPWR VPWR sky130_fd_sc_hd__fill_1
X_6989_ _7398_/CLK _6989_/D _6269_/Y VGND VGND VPWR VPWR _6989_/Q sky130_fd_sc_hd__dfrtp_2
XFILLER_21_360 VGND VGND VPWR VPWR sky130_fd_sc_hd__decap_3
XFILLER_21_393 VGND VGND VPWR VPWR sky130_fd_sc_hd__decap_3
XFILLER_31_32 VGND VGND VPWR VPWR sky130_fd_sc_hd__fill_1
XFILLER_31_43 VGND VGND VPWR VPWR sky130_fd_sc_hd__fill_1
XFILLER_5_526 VGND VGND VPWR VPWR sky130_fd_sc_hd__fill_1
XFILLER_5_537 VGND VGND VPWR VPWR sky130_fd_sc_hd__fill_2
XFILLER_107_443 VGND VGND VPWR VPWR sky130_fd_sc_hd__fill_2
XFILLER_5_559 VGND VGND VPWR VPWR sky130_fd_sc_hd__fill_1
XTAP_TAPCELL_ROW_8_331 VGND VPWR sky130_fd_sc_hd__tapvpwrvgnd_1
XFILLER_0_231 VGND VGND VPWR VPWR sky130_fd_sc_hd__decap_3
XFILLER_0_253 VGND VGND VPWR VPWR sky130_fd_sc_hd__decap_3
XFILLER_88_360 VGND VGND VPWR VPWR sky130_fd_sc_hd__decap_3
XFILLER_95_319 VGND VGND VPWR VPWR sky130_fd_sc_hd__decap_3
XFILLER_0_275 VGND VGND VPWR VPWR sky130_fd_sc_hd__decap_3
XFILLER_48_224 VGND VGND VPWR VPWR sky130_fd_sc_hd__decap_3
XFILLER_48_235 VGND VGND VPWR VPWR sky130_fd_sc_hd__fill_1
XFILLER_76_522 VGND VGND VPWR VPWR sky130_fd_sc_hd__decap_3
XFILLER_76_533 VGND VGND VPWR VPWR sky130_fd_sc_hd__decap_3
XFILLER_88_393 VGND VGND VPWR VPWR sky130_fd_sc_hd__fill_2
XFILLER_48_268 VGND VGND VPWR VPWR sky130_fd_sc_hd__decap_3
XFILLER_56_40 VGND VGND VPWR VPWR sky130_fd_sc_hd__decap_3
XFILLER_17_600 VGND VGND VPWR VPWR sky130_fd_sc_hd__decap_3
XFILLER_29_460 VGND VGND VPWR VPWR sky130_fd_sc_hd__fill_1
XFILLER_29_482 VGND VGND VPWR VPWR sky130_fd_sc_hd__fill_1
XFILLER_48_279 VGND VGND VPWR VPWR sky130_fd_sc_hd__decap_3
XFILLER_91_514 VGND VGND VPWR VPWR sky130_fd_sc_hd__decap_3
XFILLER_17_644 VGND VGND VPWR VPWR sky130_fd_sc_hd__decap_3
XFILLER_44_441 VGND VGND VPWR VPWR sky130_fd_sc_hd__fill_1
XFILLER_91_547 VGND VGND VPWR VPWR sky130_fd_sc_hd__decap_3
XTAP_TAPCELL_ROW_102_1409 VGND VPWR sky130_fd_sc_hd__tapvpwrvgnd_1
XFILLER_31_102 VGND VGND VPWR VPWR sky130_fd_sc_hd__fill_2
XFILLER_31_113 VGND VGND VPWR VPWR sky130_fd_sc_hd__decap_3
XFILLER_32_625 VGND VGND VPWR VPWR sky130_fd_sc_hd__decap_3
XFILLER_71_293 VGND VGND VPWR VPWR sky130_fd_sc_hd__fill_1
XFILLER_31_157 VGND VGND VPWR VPWR sky130_fd_sc_hd__decap_3
XFILLER_72_94 VGND VGND VPWR VPWR sky130_fd_sc_hd__decap_3
XPHY_EDGE_ROW_59_Right_59 VGND VGND VPWR VPWR sky130_fd_sc_hd__decap_3
XFILLER_12_393 VGND VGND VPWR VPWR sky130_fd_sc_hd__decap_3
XTAP_TAPCELL_ROW_14_399 VGND VPWR sky130_fd_sc_hd__tapvpwrvgnd_1
XFILLER_99_603 VGND VGND VPWR VPWR sky130_fd_sc_hd__fill_1
X_4340_ _7223_/Q _4349_/B1 _4338_/X _4339_/X VGND VGND VPWR VPWR _4340_/X sky130_fd_sc_hd__a211o_2
XFILLER_98_113 VGND VGND VPWR VPWR sky130_fd_sc_hd__fill_2
XFILLER_4_581 VGND VGND VPWR VPWR sky130_fd_sc_hd__decap_3
XFILLER_4_592 VGND VGND VPWR VPWR sky130_fd_sc_hd__decap_3
X_4271_ _4271_/A _4271_/B _4271_/C _4270_/Y VGND VGND VPWR VPWR _4271_/X sky130_fd_sc_hd__or4b_2
XFILLER_99_647 VGND VGND VPWR VPWR sky130_fd_sc_hd__fill_1
XFILLER_98_179 VGND VGND VPWR VPWR sky130_fd_sc_hd__decap_3
XFILLER_98_168 VGND VGND VPWR VPWR sky130_fd_sc_hd__decap_3
XFILLER_97_91 VGND VGND VPWR VPWR sky130_fd_sc_hd__decap_3
XFILLER_39_202 VGND VGND VPWR VPWR sky130_fd_sc_hd__decap_3
XFILLER_67_511 VGND VGND VPWR VPWR sky130_fd_sc_hd__fill_2
XFILLER_79_371 VGND VGND VPWR VPWR sky130_fd_sc_hd__decap_3
XFILLER_79_393 VGND VGND VPWR VPWR sky130_fd_sc_hd__fill_1
XPHY_EDGE_ROW_68_Right_68 VGND VGND VPWR VPWR sky130_fd_sc_hd__decap_3
XFILLER_39_279 VGND VGND VPWR VPWR sky130_fd_sc_hd__fill_1
XFILLER_82_536 VGND VGND VPWR VPWR sky130_fd_sc_hd__decap_3
XFILLER_94_396 VGND VGND VPWR VPWR sky130_fd_sc_hd__decap_3
XTAP_TAPCELL_ROW_68_1017 VGND VPWR sky130_fd_sc_hd__tapvpwrvgnd_1
XPHY_EDGE_ROW_6_Left_115 VGND VGND VPWR VPWR sky130_fd_sc_hd__decap_3
XFILLER_82_547 VGND VGND VPWR VPWR sky130_fd_sc_hd__decap_3
X_6912_ _6943_/CLK _6912_/D VGND VGND VPWR VPWR _6912_/Q sky130_fd_sc_hd__dfxtp_2
XFILLER_35_452 VGND VGND VPWR VPWR sky130_fd_sc_hd__decap_3
X_6843_ clkload3/A _6843_/D VGND VGND VPWR VPWR _6843_/Q sky130_fd_sc_hd__dfxtp_2
XFILLER_23_647 VGND VGND VPWR VPWR sky130_fd_sc_hd__fill_1
XFILLER_90_580 VGND VGND VPWR VPWR sky130_fd_sc_hd__decap_3
X_6774_ _6976_/CLK _6774_/D VGND VGND VPWR VPWR _6774_/Q sky130_fd_sc_hd__dfxtp_2
XTAP_TAPCELL_ROW_61_940 VGND VPWR sky130_fd_sc_hd__tapvpwrvgnd_1
XPHY_EDGE_ROW_77_Right_77 VGND VGND VPWR VPWR sky130_fd_sc_hd__decap_3
XFILLER_50_477 VGND VGND VPWR VPWR sky130_fd_sc_hd__fill_1
X_5725_ _7368_/Q hold909/X _5737_/S VGND VGND VPWR VPWR _6712_/D sky130_fd_sc_hd__mux2_2
X_5656_ _5656_/A _5656_/B _5656_/C VGND VGND VPWR VPWR _5665_/C sky130_fd_sc_hd__nor3_2
XTAP_TAPCELL_ROW_79_1146 VGND VPWR sky130_fd_sc_hd__tapvpwrvgnd_1
X_5587_ _5587_/A _5587_/B VGND VGND VPWR VPWR _7034_/D sky130_fd_sc_hd__and2_2
XFILLER_104_402 VGND VGND VPWR VPWR sky130_fd_sc_hd__decap_3
XFILLER_89_102 VGND VGND VPWR VPWR sky130_fd_sc_hd__fill_2
XFILLER_89_113 VGND VGND VPWR VPWR sky130_fd_sc_hd__decap_3
X_7326_ _7364_/CLK _7326_/D _6606_/Y VGND VGND VPWR VPWR _7326_/Q sky130_fd_sc_hd__dfrtp_2
XFILLER_104_424 VGND VGND VPWR VPWR sky130_fd_sc_hd__decap_3
X_7257_ _7387_/CLK _7257_/D _6537_/Y VGND VGND VPWR VPWR _7257_/Q sky130_fd_sc_hd__dfrtp_2
X_4469_ _7009_/Q _4467_/A _3332_/B _4468_/X VGND VGND VPWR VPWR _4469_/X sky130_fd_sc_hd__a31o_2
XFILLER_77_308 VGND VGND VPWR VPWR sky130_fd_sc_hd__decap_3
XPHY_EDGE_ROW_86_Right_86 VGND VGND VPWR VPWR sky130_fd_sc_hd__decap_3
XFILLER_58_533 VGND VGND VPWR VPWR sky130_fd_sc_hd__fill_2
X_7188_ _7382_/CLK _7188_/D _6468_/Y VGND VGND VPWR VPWR _7188_/Q sky130_fd_sc_hd__dfrtp_2
XFILLER_85_330 VGND VGND VPWR VPWR sky130_fd_sc_hd__fill_2
Xhold1020 _7276_/Q VGND VGND VPWR VPWR _4753_/A0 sky130_fd_sc_hd__dlygate4sd3_1
Xhold1031 _4532_/X VGND VGND VPWR VPWR _7313_/D sky130_fd_sc_hd__dlygate4sd3_1
Xhold1042 _7209_/Q VGND VGND VPWR VPWR _5241_/A0 sky130_fd_sc_hd__dlygate4sd3_1
XFILLER_18_419 VGND VGND VPWR VPWR sky130_fd_sc_hd__fill_1
XFILLER_73_536 VGND VGND VPWR VPWR sky130_fd_sc_hd__decap_3
XFILLER_85_385 VGND VGND VPWR VPWR sky130_fd_sc_hd__decap_3
XFILLER_85_396 VGND VGND VPWR VPWR sky130_fd_sc_hd__decap_3
Xhold1053 _7193_/Q VGND VGND VPWR VPWR _5274_/A0 sky130_fd_sc_hd__dlygate4sd3_1
Xhold1064 _7386_/Q VGND VGND VPWR VPWR _3860_/A0 sky130_fd_sc_hd__dlygate4sd3_1
Xhold1075 _7235_/Q VGND VGND VPWR VPWR _5186_/A sky130_fd_sc_hd__dlygate4sd3_1
XFILLER_45_238 VGND VGND VPWR VPWR sky130_fd_sc_hd__decap_3
Xhold1086 _7249_/Q VGND VGND VPWR VPWR _5142_/A0 sky130_fd_sc_hd__dlygate4sd3_1
Xhold1097 _7327_/Q VGND VGND VPWR VPWR _4505_/A0 sky130_fd_sc_hd__dlygate4sd3_1
XFILLER_26_43 VGND VGND VPWR VPWR sky130_fd_sc_hd__decap_3
XFILLER_41_400 VGND VGND VPWR VPWR sky130_fd_sc_hd__fill_1
XFILLER_60_219 VGND VGND VPWR VPWR sky130_fd_sc_hd__decap_3
XFILLER_13_113 VGND VGND VPWR VPWR sky130_fd_sc_hd__decap_3
XFILLER_14_625 VGND VGND VPWR VPWR sky130_fd_sc_hd__decap_3
XPHY_EDGE_ROW_95_Right_95 VGND VGND VPWR VPWR sky130_fd_sc_hd__decap_3
XFILLER_13_157 VGND VGND VPWR VPWR sky130_fd_sc_hd__fill_2
XFILLER_5_301 VGND VGND VPWR VPWR sky130_fd_sc_hd__decap_3
XFILLER_5_312 VGND VGND VPWR VPWR sky130_fd_sc_hd__decap_3
XTAP_TAPCELL_ROW_11_358 VGND VPWR sky130_fd_sc_hd__tapvpwrvgnd_1
XFILLER_3_36 VGND VGND VPWR VPWR sky130_fd_sc_hd__decap_3
XFILLER_107_90 VGND VGND VPWR VPWR sky130_fd_sc_hd__fill_2
XFILLER_1_573 VGND VGND VPWR VPWR sky130_fd_sc_hd__decap_3
XFILLER_95_127 VGND VGND VPWR VPWR sky130_fd_sc_hd__decap_3
XPHY_EDGE_ROW_79_Left_188 VGND VGND VPWR VPWR sky130_fd_sc_hd__decap_3
XFILLER_76_352 VGND VGND VPWR VPWR sky130_fd_sc_hd__decap_3
XFILLER_64_503 VGND VGND VPWR VPWR sky130_fd_sc_hd__decap_3
XFILLER_91_300 VGND VGND VPWR VPWR sky130_fd_sc_hd__fill_2
XFILLER_91_311 VGND VGND VPWR VPWR sky130_fd_sc_hd__fill_2
XFILLER_17_430 VGND VGND VPWR VPWR sky130_fd_sc_hd__decap_3
XFILLER_36_227 VGND VGND VPWR VPWR sky130_fd_sc_hd__fill_2
XFILLER_36_238 VGND VGND VPWR VPWR sky130_fd_sc_hd__decap_3
XFILLER_64_536 VGND VGND VPWR VPWR sky130_fd_sc_hd__fill_1
XFILLER_91_377 VGND VGND VPWR VPWR sky130_fd_sc_hd__decap_3
XTAP_TAPCELL_ROW_47_778 VGND VPWR sky130_fd_sc_hd__tapvpwrvgnd_1
XTAP_TAPCELL_ROW_19_458 VGND VPWR sky130_fd_sc_hd__tapvpwrvgnd_1
XFILLER_44_271 VGND VGND VPWR VPWR sky130_fd_sc_hd__fill_2
XFILLER_44_282 VGND VGND VPWR VPWR sky130_fd_sc_hd__decap_3
XFILLER_91_399 VGND VGND VPWR VPWR sky130_fd_sc_hd__decap_3
X_3840_ _6835_/Q _3886_/B1 _3887_/B1 _6840_/Q VGND VGND VPWR VPWR _3840_/X sky130_fd_sc_hd__a22o_2
XFILLER_20_628 VGND VGND VPWR VPWR sky130_fd_sc_hd__decap_3
XFILLER_32_477 VGND VGND VPWR VPWR sky130_fd_sc_hd__decap_3
X_3771_ _6910_/Q _3881_/A2 _3883_/A2 _6862_/Q VGND VGND VPWR VPWR _3771_/X sky130_fd_sc_hd__a22o_2
XPHY_EDGE_ROW_88_Left_197 VGND VGND VPWR VPWR sky130_fd_sc_hd__decap_3
XFILLER_8_150 VGND VGND VPWR VPWR sky130_fd_sc_hd__decap_3
XFILLER_8_172 VGND VGND VPWR VPWR sky130_fd_sc_hd__decap_3
X_6490_ _6677_/A VGND VGND VPWR VPWR _6490_/Y sky130_fd_sc_hd__inv_2
X_7111_ _7276_/CLK _7111_/D _6391_/Y VGND VGND VPWR VPWR _7111_/Q sky130_fd_sc_hd__dfrtp_2
Xoutput469 _5659_/B VGND VGND VPWR VPWR alu_result_out[1] sky130_fd_sc_hd__clkdlybuf4s25_1
Xoutput458 _5650_/Y VGND VGND VPWR VPWR alu_result_out[0] sky130_fd_sc_hd__clkdlybuf4s25_1
X_4323_ _7226_/Q _4353_/A2 _4414_/B1 _7194_/Q VGND VGND VPWR VPWR _4323_/X sky130_fd_sc_hd__a22o_2
XFILLER_99_422 VGND VGND VPWR VPWR sky130_fd_sc_hd__decap_3
XFILLER_87_617 VGND VGND VPWR VPWR sky130_fd_sc_hd__decap_3
X_7042_ _7392_/CLK _7042_/D _6322_/Y VGND VGND VPWR VPWR _7042_/Q sky130_fd_sc_hd__dfrtp_2
XTAP_TAPCELL_ROW_74_1087 VGND VPWR sky130_fd_sc_hd__tapvpwrvgnd_1
XFILLER_99_455 VGND VGND VPWR VPWR sky130_fd_sc_hd__fill_2
XFILLER_101_416 VGND VGND VPWR VPWR sky130_fd_sc_hd__decap_3
XFILLER_86_116 VGND VGND VPWR VPWR sky130_fd_sc_hd__decap_3
X_4254_ _7229_/Q _4353_/A2 _4244_/B _7042_/Q _4253_/X VGND VGND VPWR VPWR _4254_/X
+ sky130_fd_sc_hd__a221o_2
XFILLER_101_449 VGND VGND VPWR VPWR sky130_fd_sc_hd__decap_3
X_4185_ _4537_/C _5708_/S _4185_/C VGND VGND VPWR VPWR _4636_/B sky130_fd_sc_hd__and3_2
XFILLER_103_15 VGND VGND VPWR VPWR sky130_fd_sc_hd__decap_3
XFILLER_55_514 VGND VGND VPWR VPWR sky130_fd_sc_hd__decap_3
XFILLER_67_385 VGND VGND VPWR VPWR sky130_fd_sc_hd__decap_3
XFILLER_67_396 VGND VGND VPWR VPWR sky130_fd_sc_hd__decap_3
XFILLER_55_569 VGND VGND VPWR VPWR sky130_fd_sc_hd__fill_1
XFILLER_82_377 VGND VGND VPWR VPWR sky130_fd_sc_hd__decap_3
XFILLER_23_411 VGND VGND VPWR VPWR sky130_fd_sc_hd__decap_3
XFILLER_11_606 VGND VGND VPWR VPWR sky130_fd_sc_hd__decap_3
X_6826_ _6976_/CLK _6826_/D VGND VGND VPWR VPWR _6826_/Q sky130_fd_sc_hd__dfxtp_2
XFILLER_11_617 VGND VGND VPWR VPWR sky130_fd_sc_hd__decap_3
XFILLER_23_488 VGND VGND VPWR VPWR sky130_fd_sc_hd__decap_3
XFILLER_50_285 VGND VGND VPWR VPWR sky130_fd_sc_hd__fill_1
X_6757_ _6965_/CLK _6757_/D VGND VGND VPWR VPWR _6757_/Q sky130_fd_sc_hd__dfxtp_2
X_5708_ _5708_/A0 _6704_/Q _5708_/S VGND VGND VPWR VPWR _6704_/D sky130_fd_sc_hd__mux2_2
X_6688_ _6963_/CLK _6688_/D VGND VGND VPWR VPWR _6688_/Q sky130_fd_sc_hd__dfxtp_2
XFILLER_104_221 VGND VGND VPWR VPWR sky130_fd_sc_hd__fill_2
XFILLER_2_315 VGND VGND VPWR VPWR sky130_fd_sc_hd__decap_3
XFILLER_2_337 VGND VGND VPWR VPWR sky130_fd_sc_hd__fill_2
XFILLER_5_6 VGND VGND VPWR VPWR sky130_fd_sc_hd__decap_3
X_7309_ _7373_/CLK _7309_/D _6589_/Y VGND VGND VPWR VPWR _7309_/Q sky130_fd_sc_hd__dfrtp_2
XFILLER_104_243 VGND VGND VPWR VPWR sky130_fd_sc_hd__decap_3
XFILLER_104_265 VGND VGND VPWR VPWR sky130_fd_sc_hd__decap_3
XFILLER_78_617 VGND VGND VPWR VPWR sky130_fd_sc_hd__decap_3
XFILLER_77_149 VGND VGND VPWR VPWR sky130_fd_sc_hd__decap_3
XFILLER_37_31 VGND VGND VPWR VPWR sky130_fd_sc_hd__decap_3
XFILLER_58_352 VGND VGND VPWR VPWR sky130_fd_sc_hd__decap_3
XFILLER_58_374 VGND VGND VPWR VPWR sky130_fd_sc_hd__fill_2
XFILLER_58_385 VGND VGND VPWR VPWR sky130_fd_sc_hd__decap_3
XFILLER_85_160 VGND VGND VPWR VPWR sky130_fd_sc_hd__decap_3
XFILLER_18_227 VGND VGND VPWR VPWR sky130_fd_sc_hd__decap_3
XFILLER_18_249 VGND VGND VPWR VPWR sky130_fd_sc_hd__decap_3
XFILLER_46_536 VGND VGND VPWR VPWR sky130_fd_sc_hd__decap_3
XFILLER_61_517 VGND VGND VPWR VPWR sky130_fd_sc_hd__decap_3
XFILLER_73_355 VGND VGND VPWR VPWR sky130_fd_sc_hd__decap_3
XFILLER_33_219 VGND VGND VPWR VPWR sky130_fd_sc_hd__decap_3
XFILLER_73_399 VGND VGND VPWR VPWR sky130_fd_sc_hd__decap_3
XTAP_TAPCELL_ROW_44_737 VGND VPWR sky130_fd_sc_hd__tapvpwrvgnd_1
XTAP_TAPCELL_ROW_16_417 VGND VPWR sky130_fd_sc_hd__tapvpwrvgnd_1
XFILLER_53_52 VGND VGND VPWR VPWR sky130_fd_sc_hd__decap_3
XFILLER_14_488 VGND VGND VPWR VPWR sky130_fd_sc_hd__decap_3
XFILLER_53_74 VGND VGND VPWR VPWR sky130_fd_sc_hd__fill_2
XFILLER_41_296 VGND VGND VPWR VPWR sky130_fd_sc_hd__decap_3
XFILLER_6_610 VGND VGND VPWR VPWR sky130_fd_sc_hd__decap_3
XFILLER_6_643 VGND VGND VPWR VPWR sky130_fd_sc_hd__fill_1
XFILLER_5_175 VGND VGND VPWR VPWR sky130_fd_sc_hd__decap_3
XFILLER_5_197 VGND VGND VPWR VPWR sky130_fd_sc_hd__decap_3
XFILLER_68_127 VGND VGND VPWR VPWR sky130_fd_sc_hd__fill_2
XFILLER_68_138 VGND VGND VPWR VPWR sky130_fd_sc_hd__fill_2
XFILLER_37_514 VGND VGND VPWR VPWR sky130_fd_sc_hd__fill_1
XFILLER_49_352 VGND VGND VPWR VPWR sky130_fd_sc_hd__decap_3
XFILLER_64_300 VGND VGND VPWR VPWR sky130_fd_sc_hd__decap_3
XFILLER_76_160 VGND VGND VPWR VPWR sky130_fd_sc_hd__decap_3
XFILLER_83_108 VGND VGND VPWR VPWR sky130_fd_sc_hd__decap_3
XFILLER_37_536 VGND VGND VPWR VPWR sky130_fd_sc_hd__decap_3
XFILLER_49_385 VGND VGND VPWR VPWR sky130_fd_sc_hd__decap_3
XFILLER_91_130 VGND VGND VPWR VPWR sky130_fd_sc_hd__decap_3
XFILLER_52_539 VGND VGND VPWR VPWR sky130_fd_sc_hd__decap_3
X_4941_ _4811_/C _4936_/Y _4940_/Y VGND VGND VPWR VPWR _5657_/C sky130_fd_sc_hd__a21o_2
XPHY_EDGE_ROW_96_Left_205 VGND VGND VPWR VPWR sky130_fd_sc_hd__decap_3
XFILLER_32_230 VGND VGND VPWR VPWR sky130_fd_sc_hd__decap_3
X_4872_ _4872_/A _4872_/B VGND VGND VPWR VPWR _4872_/X sky130_fd_sc_hd__and2_2
XFILLER_20_414 VGND VGND VPWR VPWR sky130_fd_sc_hd__decap_3
X_6611_ _6611_/A VGND VGND VPWR VPWR _6611_/Y sky130_fd_sc_hd__inv_2
X_3823_ _6947_/Q _3823_/A2 _3912_/B1 _6959_/Q VGND VGND VPWR VPWR _3823_/X sky130_fd_sc_hd__a22o_2
X_6542_ _6637_/A VGND VGND VPWR VPWR _6542_/Y sky130_fd_sc_hd__inv_2
X_3754_ _3754_/A1 _4799_/A _3753_/X VGND VGND VPWR VPWR _7397_/D sky130_fd_sc_hd__o21a_2
X_6473_ _6541_/A VGND VGND VPWR VPWR _6473_/Y sky130_fd_sc_hd__inv_2
XTAP_TAPCELL_ROW_76_1105 VGND VPWR sky130_fd_sc_hd__tapvpwrvgnd_1
XFILLER_87_414 VGND VGND VPWR VPWR sky130_fd_sc_hd__decap_3
X_5286_ _5286_/A0 _5139_/X _5292_/S VGND VGND VPWR VPWR _7186_/D sky130_fd_sc_hd__mux2_2
X_4306_ _7288_/Q _4352_/A2 _4335_/B1 _7096_/Q VGND VGND VPWR VPWR _4311_/A sky130_fd_sc_hd__a22o_2
XFILLER_101_246 VGND VGND VPWR VPWR sky130_fd_sc_hd__decap_3
X_7025_ _7372_/CLK _7025_/D _6305_/Y VGND VGND VPWR VPWR _7025_/Q sky130_fd_sc_hd__dfrtp_2
X_4237_ _7259_/Q _4601_/S _4236_/X VGND VGND VPWR VPWR _4237_/X sky130_fd_sc_hd__a21o_2
XFILLER_28_536 VGND VGND VPWR VPWR sky130_fd_sc_hd__decap_3
XFILLER_28_547 VGND VGND VPWR VPWR sky130_fd_sc_hd__fill_2
XFILLER_55_311 VGND VGND VPWR VPWR sky130_fd_sc_hd__fill_2
XFILLER_67_193 VGND VGND VPWR VPWR sky130_fd_sc_hd__decap_3
XFILLER_74_29 VGND VGND VPWR VPWR sky130_fd_sc_hd__fill_1
X_4168_ _7046_/Q _4429_/A2 _4272_/B _7361_/Q _4167_/X VGND VGND VPWR VPWR _4168_/X
+ sky130_fd_sc_hd__a221o_2
XTAP_TAPCELL_ROW_87_1234 VGND VPWR sky130_fd_sc_hd__tapvpwrvgnd_1
XFILLER_15_208 VGND VGND VPWR VPWR sky130_fd_sc_hd__fill_2
XFILLER_82_141 VGND VGND VPWR VPWR sky130_fd_sc_hd__decap_3
X_4099_ _7301_/Q _4478_/S _4261_/B1 _7173_/Q _4098_/X VGND VGND VPWR VPWR _4099_/X
+ sky130_fd_sc_hd__a221o_2
XFILLER_70_325 VGND VGND VPWR VPWR sky130_fd_sc_hd__decap_3
XFILLER_82_163 VGND VGND VPWR VPWR sky130_fd_sc_hd__fill_1
XFILLER_23_241 VGND VGND VPWR VPWR sky130_fd_sc_hd__decap_3
XFILLER_70_347 VGND VGND VPWR VPWR sky130_fd_sc_hd__decap_3
XFILLER_11_414 VGND VGND VPWR VPWR sky130_fd_sc_hd__decap_3
XFILLER_51_572 VGND VGND VPWR VPWR sky130_fd_sc_hd__decap_3
X_6809_ _6966_/CLK _6809_/D VGND VGND VPWR VPWR _6809_/Q sky130_fd_sc_hd__dfxtp_2
XTAP_TAPCELL_ROW_41_707 VGND VPWR sky130_fd_sc_hd__tapvpwrvgnd_1
XFILLER_11_458 VGND VGND VPWR VPWR sky130_fd_sc_hd__decap_3
XFILLER_23_66 VGND VGND VPWR VPWR sky130_fd_sc_hd__fill_2
XTAP_TAPCELL_ROW_98_1363 VGND VPWR sky130_fd_sc_hd__tapvpwrvgnd_1
XTAP_TAPCELL_ROW_21_475 VGND VPWR sky130_fd_sc_hd__tapvpwrvgnd_1
XFILLER_3_635 VGND VGND VPWR VPWR sky130_fd_sc_hd__decap_3
XFILLER_105_552 VGND VGND VPWR VPWR sky130_fd_sc_hd__decap_3
XFILLER_2_123 VGND VGND VPWR VPWR sky130_fd_sc_hd__fill_1
XFILLER_2_156 VGND VGND VPWR VPWR sky130_fd_sc_hd__decap_3
XFILLER_3_3 VGND VGND VPWR VPWR sky130_fd_sc_hd__decap_3
XFILLER_2_189 VGND VGND VPWR VPWR sky130_fd_sc_hd__decap_3
XFILLER_78_469 VGND VGND VPWR VPWR sky130_fd_sc_hd__decap_3
XFILLER_19_514 VGND VGND VPWR VPWR sky130_fd_sc_hd__decap_3
XFILLER_48_85 VGND VGND VPWR VPWR sky130_fd_sc_hd__decap_3
XFILLER_46_333 VGND VGND VPWR VPWR sky130_fd_sc_hd__decap_3
XFILLER_58_193 VGND VGND VPWR VPWR sky130_fd_sc_hd__decap_3
XFILLER_74_642 VGND VGND VPWR VPWR sky130_fd_sc_hd__fill_2
XFILLER_86_491 VGND VGND VPWR VPWR sky130_fd_sc_hd__decap_3
XTAP_TAPCELL_ROW_29_564 VGND VPWR sky130_fd_sc_hd__tapvpwrvgnd_1
XFILLER_34_539 VGND VGND VPWR VPWR sky130_fd_sc_hd__decap_3
XFILLER_46_377 VGND VGND VPWR VPWR sky130_fd_sc_hd__decap_3
XFILLER_46_388 VGND VGND VPWR VPWR sky130_fd_sc_hd__decap_3
XFILLER_61_325 VGND VGND VPWR VPWR sky130_fd_sc_hd__decap_3
XFILLER_64_51 VGND VGND VPWR VPWR sky130_fd_sc_hd__decap_3
XFILLER_64_62 VGND VGND VPWR VPWR sky130_fd_sc_hd__decap_3
XTAP_TAPCELL_ROW_57_895 VGND VPWR sky130_fd_sc_hd__tapvpwrvgnd_1
XTAP_TAPCELL_ROW_107_1470 VGND VPWR sky130_fd_sc_hd__tapvpwrvgnd_1
XFILLER_14_230 VGND VGND VPWR VPWR sky130_fd_sc_hd__decap_3
XFILLER_27_591 VGND VGND VPWR VPWR sky130_fd_sc_hd__decap_3
XFILLER_14_274 VGND VGND VPWR VPWR sky130_fd_sc_hd__decap_3
XFILLER_10_480 VGND VGND VPWR VPWR sky130_fd_sc_hd__decap_3
Xhold908 _6689_/Q VGND VGND VPWR VPWR hold908/X sky130_fd_sc_hd__dlygate4sd3_1
Xhold919 _6714_/Q VGND VGND VPWR VPWR hold919/X sky130_fd_sc_hd__dlygate4sd3_1
X_3470_ _3468_/X _3424_/S _4537_/C _4537_/B VGND VGND VPWR VPWR _3545_/B sky130_fd_sc_hd__o2bb2a_2
XFILLER_36_3 VGND VGND VPWR VPWR sky130_fd_sc_hd__fill_1
X_5140_ _7250_/Q _5139_/X _5142_/S VGND VGND VPWR VPWR _7250_/D sky130_fd_sc_hd__mux2_2
XFILLER_96_200 VGND VGND VPWR VPWR sky130_fd_sc_hd__fill_1
XFILLER_57_609 VGND VGND VPWR VPWR sky130_fd_sc_hd__decap_3
XFILLER_69_458 VGND VGND VPWR VPWR sky130_fd_sc_hd__decap_3
X_5071_ _5071_/A _5071_/B VGND VGND VPWR VPWR _5072_/C sky130_fd_sc_hd__nand2_2
XTAP_TAPCELL_ROW_71_1046 VGND VPWR sky130_fd_sc_hd__tapvpwrvgnd_1
XFILLER_96_222 VGND VGND VPWR VPWR sky130_fd_sc_hd__fill_2
XFILLER_56_108 VGND VGND VPWR VPWR sky130_fd_sc_hd__decap_3
XFILLER_37_311 VGND VGND VPWR VPWR sky130_fd_sc_hd__decap_3
XFILLER_49_160 VGND VGND VPWR VPWR sky130_fd_sc_hd__decap_3
XFILLER_49_193 VGND VGND VPWR VPWR sky130_fd_sc_hd__decap_3
XFILLER_65_620 VGND VGND VPWR VPWR sky130_fd_sc_hd__decap_3
XFILLER_96_299 VGND VGND VPWR VPWR sky130_fd_sc_hd__decap_3
XFILLER_52_303 VGND VGND VPWR VPWR sky130_fd_sc_hd__decap_3
XFILLER_64_163 VGND VGND VPWR VPWR sky130_fd_sc_hd__decap_3
XFILLER_80_634 VGND VGND VPWR VPWR sky130_fd_sc_hd__decap_3
XFILLER_80_645 VGND VGND VPWR VPWR sky130_fd_sc_hd__decap_3
X_4924_ _4920_/A _4922_/X _4923_/Y VGND VGND VPWR VPWR _4924_/X sky130_fd_sc_hd__a21o_2
XFILLER_33_561 VGND VGND VPWR VPWR sky130_fd_sc_hd__fill_1
XFILLER_100_38 VGND VGND VPWR VPWR sky130_fd_sc_hd__decap_3
XFILLER_100_49 VGND VGND VPWR VPWR sky130_fd_sc_hd__decap_3
XFILLER_20_200 VGND VGND VPWR VPWR sky130_fd_sc_hd__decap_3
XFILLER_20_233 VGND VGND VPWR VPWR sky130_fd_sc_hd__decap_3
XFILLER_33_583 VGND VGND VPWR VPWR sky130_fd_sc_hd__decap_3
X_4855_ _4855_/A _4855_/B _4854_/X VGND VGND VPWR VPWR _5655_/D sky130_fd_sc_hd__or3b_4
XTAP_TAPCELL_ROW_82_1175 VGND VPWR sky130_fd_sc_hd__tapvpwrvgnd_1
XFILLER_20_244 VGND VGND VPWR VPWR sky130_fd_sc_hd__decap_3
X_4786_ _4795_/A _4795_/B _4648_/A VGND VGND VPWR VPWR _4787_/B sky130_fd_sc_hd__a21o_2
X_3806_ _6966_/Q _3884_/A2 _3824_/B1 _6954_/Q _3805_/X VGND VGND VPWR VPWR _3806_/X
+ sky130_fd_sc_hd__a221o_2
X_6525_ _6619_/A VGND VGND VPWR VPWR _6525_/Y sky130_fd_sc_hd__inv_2
X_3737_ _6752_/Q _3912_/A2 _3911_/B1 _6746_/Q VGND VGND VPWR VPWR _3737_/X sky130_fd_sc_hd__a22o_2
XFILLER_106_305 VGND VGND VPWR VPWR sky130_fd_sc_hd__decap_3
X_6456_ _6618_/A VGND VGND VPWR VPWR _6456_/Y sky130_fd_sc_hd__inv_2
X_3668_ _6943_/Q _3862_/A2 _3883_/B1 _6895_/Q VGND VGND VPWR VPWR _3668_/X sky130_fd_sc_hd__a22o_2
X_6387_ _6613_/A VGND VGND VPWR VPWR _6387_/Y sky130_fd_sc_hd__inv_2
X_5407_ _5407_/A0 _5061_/X _5427_/S VGND VGND VPWR VPWR _7130_/D sky130_fd_sc_hd__mux2_2
X_3599_ _3599_/A _3600_/A VGND VGND VPWR VPWR _4614_/C sky130_fd_sc_hd__nor2_2
XFILLER_0_605 VGND VGND VPWR VPWR sky130_fd_sc_hd__decap_3
XFILLER_102_511 VGND VGND VPWR VPWR sky130_fd_sc_hd__decap_3
X_5338_ _5338_/A0 _5061_/X _5358_/S VGND VGND VPWR VPWR _7162_/D sky130_fd_sc_hd__mux2_2
XFILLER_102_533 VGND VGND VPWR VPWR sky130_fd_sc_hd__decap_3
XFILLER_47_119 VGND VGND VPWR VPWR sky130_fd_sc_hd__fill_1
XFILLER_75_417 VGND VGND VPWR VPWR sky130_fd_sc_hd__decap_3
XFILLER_87_288 VGND VGND VPWR VPWR sky130_fd_sc_hd__decap_3
X_7008_ _7373_/CLK _7008_/D _6288_/Y VGND VGND VPWR VPWR _7008_/Q sky130_fd_sc_hd__dfrtp_2
XFILLER_28_333 VGND VGND VPWR VPWR sky130_fd_sc_hd__decap_3
XFILLER_56_642 VGND VGND VPWR VPWR sky130_fd_sc_hd__fill_2
XFILLER_87_299 VGND VGND VPWR VPWR sky130_fd_sc_hd__decap_3
XFILLER_18_88 VGND VGND VPWR VPWR sky130_fd_sc_hd__decap_3
XFILLER_28_377 VGND VGND VPWR VPWR sky130_fd_sc_hd__fill_2
XFILLER_34_21 VGND VGND VPWR VPWR sky130_fd_sc_hd__decap_3
XFILLER_55_196 VGND VGND VPWR VPWR sky130_fd_sc_hd__decap_3
XFILLER_70_133 VGND VGND VPWR VPWR sky130_fd_sc_hd__decap_3
XFILLER_70_144 VGND VGND VPWR VPWR sky130_fd_sc_hd__fill_2
XTAP_TAPCELL_ROW_54_854 VGND VPWR sky130_fd_sc_hd__tapvpwrvgnd_1
XTAP_TAPCELL_ROW_26_534 VGND VPWR sky130_fd_sc_hd__tapvpwrvgnd_1
XFILLER_31_509 VGND VGND VPWR VPWR sky130_fd_sc_hd__decap_3
XFILLER_51_380 VGND VGND VPWR VPWR sky130_fd_sc_hd__decap_3
XFILLER_11_233 VGND VGND VPWR VPWR sky130_fd_sc_hd__decap_3
XFILLER_11_299 VGND VGND VPWR VPWR sky130_fd_sc_hd__decap_3
XFILLER_7_237 VGND VGND VPWR VPWR sky130_fd_sc_hd__decap_3
XFILLER_3_443 VGND VGND VPWR VPWR sky130_fd_sc_hd__decap_3
XFILLER_78_200 VGND VGND VPWR VPWR sky130_fd_sc_hd__decap_3
XFILLER_105_393 VGND VGND VPWR VPWR sky130_fd_sc_hd__decap_3
XFILLER_39_609 VGND VGND VPWR VPWR sky130_fd_sc_hd__decap_3
XFILLER_78_222 VGND VGND VPWR VPWR sky130_fd_sc_hd__fill_1
XFILLER_78_233 VGND VGND VPWR VPWR sky130_fd_sc_hd__decap_3
XFILLER_19_300 VGND VGND VPWR VPWR sky130_fd_sc_hd__decap_3
XFILLER_19_322 VGND VGND VPWR VPWR sky130_fd_sc_hd__decap_3
XFILLER_47_620 VGND VGND VPWR VPWR sky130_fd_sc_hd__decap_3
XFILLER_93_236 VGND VGND VPWR VPWR sky130_fd_sc_hd__decap_3
XFILLER_19_355 VGND VGND VPWR VPWR sky130_fd_sc_hd__decap_3
XFILLER_46_130 VGND VGND VPWR VPWR sky130_fd_sc_hd__decap_3
XFILLER_46_141 VGND VGND VPWR VPWR sky130_fd_sc_hd__decap_3
XFILLER_81_409 VGND VGND VPWR VPWR sky130_fd_sc_hd__decap_3
XFILLER_19_388 VGND VGND VPWR VPWR sky130_fd_sc_hd__decap_3
XFILLER_46_185 VGND VGND VPWR VPWR sky130_fd_sc_hd__decap_3
XFILLER_74_483 VGND VGND VPWR VPWR sky130_fd_sc_hd__fill_1
XFILLER_34_347 VGND VGND VPWR VPWR sky130_fd_sc_hd__decap_3
XFILLER_62_645 VGND VGND VPWR VPWR sky130_fd_sc_hd__decap_3
XFILLER_15_561 VGND VGND VPWR VPWR sky130_fd_sc_hd__decap_3
XFILLER_61_155 VGND VGND VPWR VPWR sky130_fd_sc_hd__decap_3
XFILLER_15_594 VGND VGND VPWR VPWR sky130_fd_sc_hd__decap_3
XFILLER_61_188 VGND VGND VPWR VPWR sky130_fd_sc_hd__decap_3
X_4640_ _4938_/B _4918_/A VGND VGND VPWR VPWR _4640_/Y sky130_fd_sc_hd__nor2_2
X_6310_ _6635_/A VGND VGND VPWR VPWR _6310_/Y sky130_fd_sc_hd__inv_2
X_4571_ _7295_/Q _4573_/B VGND VGND VPWR VPWR _7295_/D sky130_fd_sc_hd__and2_2
X_7290_ _7356_/CLK _7290_/D _6570_/Y VGND VGND VPWR VPWR _7290_/Q sky130_fd_sc_hd__dfrtp_2
Xhold705 _6869_/Q VGND VGND VPWR VPWR _6869_/D sky130_fd_sc_hd__dlygate4sd3_1
Xhold716 _6783_/Q VGND VGND VPWR VPWR _6783_/D sky130_fd_sc_hd__dlygate4sd3_1
Xhold727 _6761_/Q VGND VGND VPWR VPWR _6761_/D sky130_fd_sc_hd__dlygate4sd3_1
X_3522_ _5118_/C _4938_/A _4764_/B VGND VGND VPWR VPWR _5020_/A sky130_fd_sc_hd__nand3_2
Xhold738 _6875_/Q VGND VGND VPWR VPWR _6875_/D sky130_fd_sc_hd__dlygate4sd3_1
Xhold749 _6864_/Q VGND VGND VPWR VPWR _6864_/D sky130_fd_sc_hd__dlygate4sd3_1
X_3453_ _7218_/Q _4307_/A2 _4346_/B1 _7378_/Q VGND VGND VPWR VPWR _3453_/X sky130_fd_sc_hd__a22o_2
XFILLER_103_308 VGND VGND VPWR VPWR sky130_fd_sc_hd__decap_3
XFILLER_69_233 VGND VGND VPWR VPWR sky130_fd_sc_hd__decap_3
X_3384_ _7315_/Q _3994_/S _4532_/S _7283_/Q VGND VGND VPWR VPWR _3384_/X sky130_fd_sc_hd__a22o_2
XFILLER_97_564 VGND VGND VPWR VPWR sky130_fd_sc_hd__decap_3
XFILLER_57_439 VGND VGND VPWR VPWR sky130_fd_sc_hd__fill_2
X_5054_ _5054_/A VGND VGND VPWR VPWR _5054_/Y sky130_fd_sc_hd__inv_2
XFILLER_38_642 VGND VGND VPWR VPWR sky130_fd_sc_hd__fill_2
XFILLER_25_325 VGND VGND VPWR VPWR sky130_fd_sc_hd__decap_3
XFILLER_37_163 VGND VGND VPWR VPWR sky130_fd_sc_hd__decap_3
XFILLER_53_623 VGND VGND VPWR VPWR sky130_fd_sc_hd__decap_3
XTAP_TAPCELL_ROW_84_1204 VGND VPWR sky130_fd_sc_hd__tapvpwrvgnd_1
XFILLER_52_133 VGND VGND VPWR VPWR sky130_fd_sc_hd__decap_3
XFILLER_80_442 VGND VGND VPWR VPWR sky130_fd_sc_hd__decap_3
XFILLER_40_306 VGND VGND VPWR VPWR sky130_fd_sc_hd__fill_2
XFILLER_52_155 VGND VGND VPWR VPWR sky130_fd_sc_hd__decap_3
XFILLER_52_177 VGND VGND VPWR VPWR sky130_fd_sc_hd__decap_3
XTAP_TAPCELL_ROW_23_504 VGND VPWR sky130_fd_sc_hd__tapvpwrvgnd_1
XFILLER_21_520 VGND VGND VPWR VPWR sky130_fd_sc_hd__decap_3
X_4907_ _4948_/A _4888_/B _4903_/X _4906_/X VGND VGND VPWR VPWR _4907_/Y sky130_fd_sc_hd__o31ai_4
XTAP_TAPCELL_ROW_51_824 VGND VPWR sky130_fd_sc_hd__tapvpwrvgnd_1
XFILLER_21_542 VGND VGND VPWR VPWR sky130_fd_sc_hd__fill_1
X_4769_ _4969_/B _4741_/X _4761_/Y _4768_/Y VGND VGND VPWR VPWR _5663_/A sky130_fd_sc_hd__a31o_2
XTAP_TAPCELL_ROW_31_592 VGND VPWR sky130_fd_sc_hd__tapvpwrvgnd_1
XFILLER_20_23 VGND VGND VPWR VPWR sky130_fd_sc_hd__decap_3
XFILLER_4_229 VGND VGND VPWR VPWR sky130_fd_sc_hd__decap_3
X_6508_ _6609_/A VGND VGND VPWR VPWR _6508_/Y sky130_fd_sc_hd__inv_2
XTAP_TAPCELL_ROW_95_1322 VGND VPWR sky130_fd_sc_hd__tapvpwrvgnd_1
X_6439_ _6624_/A VGND VGND VPWR VPWR _6439_/Y sky130_fd_sc_hd__inv_2
XFILLER_0_402 VGND VGND VPWR VPWR sky130_fd_sc_hd__decap_3
XFILLER_0_413 VGND VGND VPWR VPWR sky130_fd_sc_hd__decap_3
XFILLER_0_446 VGND VGND VPWR VPWR sky130_fd_sc_hd__fill_2
XFILLER_102_330 VGND VGND VPWR VPWR sky130_fd_sc_hd__decap_3
XFILLER_88_542 VGND VGND VPWR VPWR sky130_fd_sc_hd__decap_3
XFILLER_102_363 VGND VGND VPWR VPWR sky130_fd_sc_hd__fill_1
XFILLER_48_417 VGND VGND VPWR VPWR sky130_fd_sc_hd__decap_3
XTAP_TAPCELL_ROW_59_913 VGND VPWR sky130_fd_sc_hd__tapvpwrvgnd_1
XFILLER_29_620 VGND VGND VPWR VPWR sky130_fd_sc_hd__decap_3
XFILLER_29_65 VGND VGND VPWR VPWR sky130_fd_sc_hd__decap_3
XFILLER_75_214 VGND VGND VPWR VPWR sky130_fd_sc_hd__decap_3
XFILLER_28_130 VGND VGND VPWR VPWR sky130_fd_sc_hd__decap_3
XFILLER_28_141 VGND VGND VPWR VPWR sky130_fd_sc_hd__decap_3
XFILLER_75_247 VGND VGND VPWR VPWR sky130_fd_sc_hd__decap_3
XFILLER_56_483 VGND VGND VPWR VPWR sky130_fd_sc_hd__decap_3
Xplace409 _3380_/Y VGND VGND VPWR VPWR _4285_/B1 sky130_fd_sc_hd__buf_2
XTAP_TAPCELL_ROW_3_273 VGND VPWR sky130_fd_sc_hd__tapvpwrvgnd_1
XFILLER_16_347 VGND VGND VPWR VPWR sky130_fd_sc_hd__decap_3
XFILLER_43_111 VGND VGND VPWR VPWR sky130_fd_sc_hd__fill_1
XFILLER_43_122 VGND VGND VPWR VPWR sky130_fd_sc_hd__decap_3
XFILLER_44_634 VGND VGND VPWR VPWR sky130_fd_sc_hd__decap_3
XFILLER_44_645 VGND VGND VPWR VPWR sky130_fd_sc_hd__decap_3
XTAP_TAPCELL_ROW_39_681 VGND VPWR sky130_fd_sc_hd__tapvpwrvgnd_1
XFILLER_43_177 VGND VGND VPWR VPWR sky130_fd_sc_hd__decap_3
XFILLER_71_464 VGND VGND VPWR VPWR sky130_fd_sc_hd__decap_3
XFILLER_71_497 VGND VGND VPWR VPWR sky130_fd_sc_hd__decap_3
XFILLER_12_531 VGND VGND VPWR VPWR sky130_fd_sc_hd__fill_1
XFILLER_12_542 VGND VGND VPWR VPWR sky130_fd_sc_hd__decap_3
XFILLER_12_564 VGND VGND VPWR VPWR sky130_fd_sc_hd__decap_3
XFILLER_61_63 VGND VGND VPWR VPWR sky130_fd_sc_hd__decap_3
XFILLER_61_96 VGND VGND VPWR VPWR sky130_fd_sc_hd__fill_2
XANTENNA_7 _7365_/Q VGND VGND VPWR VPWR sky130_fd_sc_hd__diode_2
XFILLER_6_47 VGND VGND VPWR VPWR sky130_fd_sc_hd__fill_2
XFILLER_3_240 VGND VGND VPWR VPWR sky130_fd_sc_hd__decap_3
XFILLER_3_262 VGND VGND VPWR VPWR sky130_fd_sc_hd__decap_3
XFILLER_98_306 VGND VGND VPWR VPWR sky130_fd_sc_hd__fill_2
XFILLER_79_520 VGND VGND VPWR VPWR sky130_fd_sc_hd__decap_3
XPHY_EDGE_ROW_60_Left_169 VGND VGND VPWR VPWR sky130_fd_sc_hd__decap_3
XFILLER_79_553 VGND VGND VPWR VPWR sky130_fd_sc_hd__decap_3
XFILLER_79_564 VGND VGND VPWR VPWR sky130_fd_sc_hd__decap_3
XFILLER_66_203 VGND VGND VPWR VPWR sky130_fd_sc_hd__decap_3
XFILLER_66_247 VGND VGND VPWR VPWR sky130_fd_sc_hd__fill_2
XFILLER_94_578 VGND VGND VPWR VPWR sky130_fd_sc_hd__fill_2
XFILLER_19_152 VGND VGND VPWR VPWR sky130_fd_sc_hd__decap_3
XFILLER_35_623 VGND VGND VPWR VPWR sky130_fd_sc_hd__decap_3
XFILLER_47_483 VGND VGND VPWR VPWR sky130_fd_sc_hd__decap_3
XFILLER_81_217 VGND VGND VPWR VPWR sky130_fd_sc_hd__decap_3
XFILLER_81_228 VGND VGND VPWR VPWR sky130_fd_sc_hd__decap_3
XFILLER_34_122 VGND VGND VPWR VPWR sky130_fd_sc_hd__fill_1
XFILLER_34_144 VGND VGND VPWR VPWR sky130_fd_sc_hd__decap_3
X_6790_ _6976_/CLK _6790_/D VGND VGND VPWR VPWR _6790_/Q sky130_fd_sc_hd__dfxtp_2
XFILLER_50_626 VGND VGND VPWR VPWR sky130_fd_sc_hd__decap_3
XFILLER_62_486 VGND VGND VPWR VPWR sky130_fd_sc_hd__decap_3
X_4623_ _4330_/B _4622_/X _5057_/B VGND VGND VPWR VPWR _4624_/A sky130_fd_sc_hd__o21ba_2
X_7342_ _7374_/CLK _7342_/D _6622_/Y VGND VGND VPWR VPWR _7342_/Q sky130_fd_sc_hd__dfrtp_2
X_4554_ _7303_/Q _4563_/B VGND VGND VPWR VPWR _7303_/D sky130_fd_sc_hd__and2_2
X_7273_ _7406_/CLK _7273_/D _6553_/Y VGND VGND VPWR VPWR _7273_/Q sky130_fd_sc_hd__dfrtp_2
X_3505_ _3505_/A _3505_/B VGND VGND VPWR VPWR _3505_/X sky130_fd_sc_hd__or2_4
XFILLER_103_105 VGND VGND VPWR VPWR sky130_fd_sc_hd__decap_3
XFILLER_89_317 VGND VGND VPWR VPWR sky130_fd_sc_hd__decap_3
Xhold579 _6884_/Q VGND VGND VPWR VPWR _6884_/D sky130_fd_sc_hd__dlygate4sd3_1
XFILLER_106_26 VGND VGND VPWR VPWR sky130_fd_sc_hd__fill_2
XFILLER_106_59 VGND VGND VPWR VPWR sky130_fd_sc_hd__decap_3
XFILLER_85_501 VGND VGND VPWR VPWR sky130_fd_sc_hd__decap_3
XTAP_TAPCELL_ROW_90_1274 VGND VPWR sky130_fd_sc_hd__tapvpwrvgnd_1
XFILLER_97_361 VGND VGND VPWR VPWR sky130_fd_sc_hd__decap_3
XFILLER_57_214 VGND VGND VPWR VPWR sky130_fd_sc_hd__fill_2
XFILLER_57_225 VGND VGND VPWR VPWR sky130_fd_sc_hd__decap_3
Xhold1202 _7145_/Q VGND VGND VPWR VPWR _5375_/A0 sky130_fd_sc_hd__dlygate4sd3_1
Xhold1213 _7330_/Q VGND VGND VPWR VPWR _3956_/A1 sky130_fd_sc_hd__dlygate4sd3_1
Xhold1224 _7330_/Q VGND VGND VPWR VPWR _4499_/A0 sky130_fd_sc_hd__dlygate4sd3_1
X_5106_ _6985_/Q _5068_/C _4467_/Y VGND VGND VPWR VPWR _5106_/X sky130_fd_sc_hd__o21a_2
XFILLER_85_556 VGND VGND VPWR VPWR sky130_fd_sc_hd__decap_3
XFILLER_85_578 VGND VGND VPWR VPWR sky130_fd_sc_hd__decap_3
X_5037_ _6988_/Q _5045_/B VGND VGND VPWR VPWR _5038_/B sky130_fd_sc_hd__nand2_2
XFILLER_26_623 VGND VGND VPWR VPWR sky130_fd_sc_hd__decap_3
XFILLER_72_206 VGND VGND VPWR VPWR sky130_fd_sc_hd__decap_3
XTAP_TAPCELL_ROW_0_221 VGND VPWR sky130_fd_sc_hd__tapvpwrvgnd_1
XFILLER_25_111 VGND VGND VPWR VPWR sky130_fd_sc_hd__fill_1
XFILLER_26_645 VGND VGND VPWR VPWR sky130_fd_sc_hd__decap_3
XFILLER_53_431 VGND VGND VPWR VPWR sky130_fd_sc_hd__decap_3
XFILLER_72_239 VGND VGND VPWR VPWR sky130_fd_sc_hd__decap_3
XFILLER_82_29 VGND VGND VPWR VPWR sky130_fd_sc_hd__decap_3
XTAP_TAPCELL_ROW_0_232 VGND VPWR sky130_fd_sc_hd__tapvpwrvgnd_1
XTAP_TAPCELL_ROW_64_971 VGND VPWR sky130_fd_sc_hd__tapvpwrvgnd_1
XTAP_TAPCELL_ROW_36_651 VGND VPWR sky130_fd_sc_hd__tapvpwrvgnd_1
XFILLER_13_328 VGND VGND VPWR VPWR sky130_fd_sc_hd__decap_3
XFILLER_25_199 VGND VGND VPWR VPWR sky130_fd_sc_hd__decap_3
XFILLER_40_125 VGND VGND VPWR VPWR sky130_fd_sc_hd__decap_3
XFILLER_41_626 VGND VGND VPWR VPWR sky130_fd_sc_hd__decap_3
XFILLER_53_497 VGND VGND VPWR VPWR sky130_fd_sc_hd__decap_3
X_6988_ _7398_/CLK _6988_/D _6268_/Y VGND VGND VPWR VPWR _6988_/Q sky130_fd_sc_hd__dfrtp_2
XFILLER_40_147 VGND VGND VPWR VPWR sky130_fd_sc_hd__decap_3
XFILLER_5_505 VGND VGND VPWR VPWR sky130_fd_sc_hd__decap_3
XFILLER_31_66 VGND VGND VPWR VPWR sky130_fd_sc_hd__fill_2
XFILLER_103_3 VGND VGND VPWR VPWR sky130_fd_sc_hd__decap_3
XTAP_TAPCELL_ROW_8_321 VGND VPWR sky130_fd_sc_hd__tapvpwrvgnd_1
XFILLER_0_221 VGND VGND VPWR VPWR sky130_fd_sc_hd__decap_3
XTAP_TAPCELL_ROW_8_332 VGND VPWR sky130_fd_sc_hd__tapvpwrvgnd_1
XFILLER_76_501 VGND VGND VPWR VPWR sky130_fd_sc_hd__fill_2
XFILLER_48_247 VGND VGND VPWR VPWR sky130_fd_sc_hd__decap_3
XFILLER_76_545 VGND VGND VPWR VPWR sky130_fd_sc_hd__decap_3
XFILLER_76_567 VGND VGND VPWR VPWR sky130_fd_sc_hd__fill_1
XFILLER_17_612 VGND VGND VPWR VPWR sky130_fd_sc_hd__decap_3
XFILLER_91_526 VGND VGND VPWR VPWR sky130_fd_sc_hd__decap_3
XFILLER_17_623 VGND VGND VPWR VPWR sky130_fd_sc_hd__decap_3
XFILLER_91_559 VGND VGND VPWR VPWR sky130_fd_sc_hd__fill_1
XFILLER_16_144 VGND VGND VPWR VPWR sky130_fd_sc_hd__decap_3
XFILLER_32_604 VGND VGND VPWR VPWR sky130_fd_sc_hd__decap_3
XFILLER_71_250 VGND VGND VPWR VPWR sky130_fd_sc_hd__decap_3
XFILLER_16_188 VGND VGND VPWR VPWR sky130_fd_sc_hd__decap_3
XFILLER_32_637 VGND VGND VPWR VPWR sky130_fd_sc_hd__decap_3
XFILLER_12_361 VGND VGND VPWR VPWR sky130_fd_sc_hd__decap_3
XFILLER_31_169 VGND VGND VPWR VPWR sky130_fd_sc_hd__decap_3
XFILLER_8_321 VGND VGND VPWR VPWR sky130_fd_sc_hd__decap_3
XFILLER_8_365 VGND VGND VPWR VPWR sky130_fd_sc_hd__decap_3
XFILLER_8_376 VGND VGND VPWR VPWR sky130_fd_sc_hd__decap_3
XFILLER_4_560 VGND VGND VPWR VPWR sky130_fd_sc_hd__decap_3
XFILLER_99_626 VGND VGND VPWR VPWR sky130_fd_sc_hd__decap_3
X_4270_ _7358_/Q _4270_/B VGND VGND VPWR VPWR _4270_/Y sky130_fd_sc_hd__nand2_2
XFILLER_98_147 VGND VGND VPWR VPWR sky130_fd_sc_hd__decap_3
XFILLER_98_125 VGND VGND VPWR VPWR sky130_fd_sc_hd__fill_2
XFILLER_67_501 VGND VGND VPWR VPWR sky130_fd_sc_hd__decap_3
XFILLER_86_309 VGND VGND VPWR VPWR sky130_fd_sc_hd__decap_3
XFILLER_100_119 VGND VGND VPWR VPWR sky130_fd_sc_hd__decap_3
XFILLER_39_214 VGND VGND VPWR VPWR sky130_fd_sc_hd__decap_3
XFILLER_39_225 VGND VGND VPWR VPWR sky130_fd_sc_hd__decap_3
XFILLER_67_556 VGND VGND VPWR VPWR sky130_fd_sc_hd__decap_3
XFILLER_67_567 VGND VGND VPWR VPWR sky130_fd_sc_hd__decap_3
XFILLER_82_515 VGND VGND VPWR VPWR sky130_fd_sc_hd__decap_3
XTAP_TAPCELL_ROW_68_1018 VGND VPWR sky130_fd_sc_hd__tapvpwrvgnd_1
XFILLER_54_239 VGND VGND VPWR VPWR sky130_fd_sc_hd__decap_3
X_6911_ _6976_/CLK _6911_/D VGND VGND VPWR VPWR _6911_/Q sky130_fd_sc_hd__dfxtp_2
XFILLER_23_604 VGND VGND VPWR VPWR sky130_fd_sc_hd__decap_3
XFILLER_62_250 VGND VGND VPWR VPWR sky130_fd_sc_hd__fill_2
X_6842_ _6958_/CLK _6842_/D VGND VGND VPWR VPWR _6842_/Q sky130_fd_sc_hd__dfxtp_2
XFILLER_22_103 VGND VGND VPWR VPWR sky130_fd_sc_hd__decap_3
XFILLER_22_125 VGND VGND VPWR VPWR sky130_fd_sc_hd__decap_3
XFILLER_23_626 VGND VGND VPWR VPWR sky130_fd_sc_hd__decap_3
XFILLER_62_261 VGND VGND VPWR VPWR sky130_fd_sc_hd__decap_3
XFILLER_90_570 VGND VGND VPWR VPWR sky130_fd_sc_hd__decap_3
XFILLER_90_592 VGND VGND VPWR VPWR sky130_fd_sc_hd__decap_3
XTAP_TAPCELL_ROW_33_610 VGND VPWR sky130_fd_sc_hd__tapvpwrvgnd_1
XFILLER_62_294 VGND VGND VPWR VPWR sky130_fd_sc_hd__decap_3
X_6773_ clkload5/A _6773_/D VGND VGND VPWR VPWR _6773_/Q sky130_fd_sc_hd__dfxtp_2
X_3985_ _7348_/Q _4526_/A0 _3996_/S VGND VGND VPWR VPWR _7348_/D sky130_fd_sc_hd__mux2_2
XTAP_TAPCELL_ROW_61_941 VGND VPWR sky130_fd_sc_hd__tapvpwrvgnd_1
XFILLER_10_309 VGND VGND VPWR VPWR sky130_fd_sc_hd__decap_3
XFILLER_22_169 VGND VGND VPWR VPWR sky130_fd_sc_hd__decap_3
XFILLER_50_489 VGND VGND VPWR VPWR sky130_fd_sc_hd__decap_3
XFILLER_30_191 VGND VGND VPWR VPWR sky130_fd_sc_hd__decap_3
X_5655_ _5655_/A _5655_/B _5655_/C _5655_/D VGND VGND VPWR VPWR _5665_/B sky130_fd_sc_hd__nor4_2
X_4606_ _5642_/A _5633_/B VGND VGND VPWR VPWR _4606_/Y sky130_fd_sc_hd__nor2_2
XTAP_TAPCELL_ROW_79_1147 VGND VPWR sky130_fd_sc_hd__tapvpwrvgnd_1
XPHY_EDGE_ROW_107_Left_216 VGND VGND VPWR VPWR sky130_fd_sc_hd__decap_3
X_7325_ _7357_/CLK _7325_/D _6605_/Y VGND VGND VPWR VPWR _7325_/Q sky130_fd_sc_hd__dfrtp_2
X_5586_ hold967/X _5595_/B _5118_/X VGND VGND VPWR VPWR _7035_/D sky130_fd_sc_hd__o21a_2
XFILLER_104_414 VGND VGND VPWR VPWR sky130_fd_sc_hd__decap_3
X_4537_ _5118_/A _4537_/B _4537_/C VGND VGND VPWR VPWR _4595_/B sky130_fd_sc_hd__or3_2
X_7256_ _7387_/CLK _7256_/D _6536_/Y VGND VGND VPWR VPWR _7256_/Q sky130_fd_sc_hd__dfrtp_2
X_4468_ _7009_/Q _5152_/B _5595_/B VGND VGND VPWR VPWR _4468_/X sky130_fd_sc_hd__o21a_2
XFILLER_104_469 VGND VGND VPWR VPWR sky130_fd_sc_hd__decap_3
XFILLER_89_147 VGND VGND VPWR VPWR sky130_fd_sc_hd__decap_3
XFILLER_89_169 VGND VGND VPWR VPWR sky130_fd_sc_hd__decap_3
X_7187_ _7349_/CLK _7187_/D _6467_/Y VGND VGND VPWR VPWR _7187_/Q sky130_fd_sc_hd__dfrtp_2
X_3419_ _7123_/Q _3407_/X _3413_/X _3418_/X VGND VGND VPWR VPWR _3419_/Y sky130_fd_sc_hd__a211oi_2
XFILLER_58_512 VGND VGND VPWR VPWR sky130_fd_sc_hd__decap_3
X_4399_ _7370_/Q _4399_/A2 _4398_/X _4429_/C1 VGND VGND VPWR VPWR _4399_/X sky130_fd_sc_hd__a211o_2
XFILLER_100_642 VGND VGND VPWR VPWR sky130_fd_sc_hd__fill_2
Xhold1010 _7201_/Q VGND VGND VPWR VPWR _5258_/A0 sky130_fd_sc_hd__dlygate4sd3_1
Xhold1021 _7184_/Q VGND VGND VPWR VPWR _5290_/A0 sky130_fd_sc_hd__dlygate4sd3_1
Xhold1032 _7225_/Q VGND VGND VPWR VPWR _5207_/A sky130_fd_sc_hd__dlygate4sd3_1
XFILLER_45_206 VGND VGND VPWR VPWR sky130_fd_sc_hd__decap_3
XFILLER_58_578 VGND VGND VPWR VPWR sky130_fd_sc_hd__fill_1
XFILLER_58_589 VGND VGND VPWR VPWR sky130_fd_sc_hd__fill_1
XFILLER_85_364 VGND VGND VPWR VPWR sky130_fd_sc_hd__decap_3
Xhold1043 _7212_/Q VGND VGND VPWR VPWR _5236_/A0 sky130_fd_sc_hd__dlygate4sd3_1
Xhold1054 _7243_/Q VGND VGND VPWR VPWR _5169_/A sky130_fd_sc_hd__dlygate4sd3_1
Xhold1065 _7188_/Q VGND VGND VPWR VPWR _5283_/B2 sky130_fd_sc_hd__dlygate4sd3_1
Xhold1076 _7267_/Q VGND VGND VPWR VPWR _4914_/A0 sky130_fd_sc_hd__dlygate4sd3_1
XFILLER_38_280 VGND VGND VPWR VPWR sky130_fd_sc_hd__decap_3
XFILLER_45_228 VGND VGND VPWR VPWR sky130_fd_sc_hd__decap_3
XFILLER_73_548 VGND VGND VPWR VPWR sky130_fd_sc_hd__decap_3
Xhold1087 _7405_/Q VGND VGND VPWR VPWR _3671_/A1 sky130_fd_sc_hd__dlygate4sd3_1
Xhold1098 _7324_/Q VGND VGND VPWR VPWR _4510_/A0 sky130_fd_sc_hd__dlygate4sd3_1
XFILLER_14_604 VGND VGND VPWR VPWR sky130_fd_sc_hd__decap_3
XFILLER_26_55 VGND VGND VPWR VPWR sky130_fd_sc_hd__fill_2
XFILLER_14_637 VGND VGND VPWR VPWR sky130_fd_sc_hd__decap_3
XFILLER_26_475 VGND VGND VPWR VPWR sky130_fd_sc_hd__fill_1
XFILLER_53_261 VGND VGND VPWR VPWR sky130_fd_sc_hd__decap_3
XFILLER_13_169 VGND VGND VPWR VPWR sky130_fd_sc_hd__decap_3
XFILLER_41_478 VGND VGND VPWR VPWR sky130_fd_sc_hd__decap_3
XFILLER_42_21 VGND VGND VPWR VPWR sky130_fd_sc_hd__decap_3
XFILLER_42_32 VGND VGND VPWR VPWR sky130_fd_sc_hd__fill_1
XTAP_TAPCELL_ROW_11_359 VGND VPWR sky130_fd_sc_hd__tapvpwrvgnd_1
XFILLER_5_324 VGND VGND VPWR VPWR sky130_fd_sc_hd__decap_3
XFILLER_1_541 VGND VGND VPWR VPWR sky130_fd_sc_hd__decap_3
XFILLER_68_309 VGND VGND VPWR VPWR sky130_fd_sc_hd__decap_3
XFILLER_1_585 VGND VGND VPWR VPWR sky130_fd_sc_hd__decap_3
XFILLER_1_596 VGND VGND VPWR VPWR sky130_fd_sc_hd__decap_3
XFILLER_49_501 VGND VGND VPWR VPWR sky130_fd_sc_hd__decap_3
XFILLER_95_139 VGND VGND VPWR VPWR sky130_fd_sc_hd__decap_3
XFILLER_76_331 VGND VGND VPWR VPWR sky130_fd_sc_hd__decap_3
XFILLER_88_191 VGND VGND VPWR VPWR sky130_fd_sc_hd__decap_3
XFILLER_36_206 VGND VGND VPWR VPWR sky130_fd_sc_hd__fill_1
XFILLER_76_386 VGND VGND VPWR VPWR sky130_fd_sc_hd__decap_3
XFILLER_29_291 VGND VGND VPWR VPWR sky130_fd_sc_hd__decap_3
XFILLER_64_559 VGND VGND VPWR VPWR sky130_fd_sc_hd__fill_1
XFILLER_91_334 VGND VGND VPWR VPWR sky130_fd_sc_hd__fill_2
XFILLER_44_250 VGND VGND VPWR VPWR sky130_fd_sc_hd__fill_2
XFILLER_51_209 VGND VGND VPWR VPWR sky130_fd_sc_hd__decap_3
XFILLER_91_356 VGND VGND VPWR VPWR sky130_fd_sc_hd__decap_3
XTAP_TAPCELL_ROW_47_779 VGND VPWR sky130_fd_sc_hd__tapvpwrvgnd_1
XTAP_TAPCELL_ROW_19_448 VGND VPWR sky130_fd_sc_hd__tapvpwrvgnd_1
XFILLER_91_389 VGND VGND VPWR VPWR sky130_fd_sc_hd__decap_3
XFILLER_20_607 VGND VGND VPWR VPWR sky130_fd_sc_hd__decap_3
XFILLER_44_294 VGND VGND VPWR VPWR sky130_fd_sc_hd__decap_3
X_3770_ _3770_/A1 _3857_/A2 _4944_/B VGND VGND VPWR VPWR _7393_/D sky130_fd_sc_hd__a21o_2
XFILLER_9_641 VGND VGND VPWR VPWR sky130_fd_sc_hd__decap_3
XFILLER_12_191 VGND VGND VPWR VPWR sky130_fd_sc_hd__decap_3
XFILLER_66_3 VGND VGND VPWR VPWR sky130_fd_sc_hd__decap_3
X_5371_ _5371_/A0 _4771_/X _5388_/S VGND VGND VPWR VPWR _7147_/D sky130_fd_sc_hd__mux2_2
X_7110_ _7366_/CLK _7110_/D _6390_/Y VGND VGND VPWR VPWR _7110_/Q sky130_fd_sc_hd__dfrtp_2
Xoutput459 _5658_/A VGND VGND VPWR VPWR alu_result_out[10] sky130_fd_sc_hd__clkdlybuf4s25_1
X_4322_ _7290_/Q _4352_/A2 _4352_/B1 _7162_/Q _4321_/X VGND VGND VPWR VPWR _4322_/X
+ sky130_fd_sc_hd__a221o_2
XFILLER_99_445 VGND VGND VPWR VPWR sky130_fd_sc_hd__decap_3
XFILLER_59_309 VGND VGND VPWR VPWR sky130_fd_sc_hd__decap_3
X_7041_ _7387_/CLK _7041_/D _6321_/Y VGND VGND VPWR VPWR _7041_/Q sky130_fd_sc_hd__dfrtp_2
X_4253_ _7389_/Q _4261_/A2 _5159_/S _7293_/Q _4252_/X VGND VGND VPWR VPWR _4253_/X
+ sky130_fd_sc_hd__a221o_2
XTAP_TAPCELL_ROW_74_1088 VGND VPWR sky130_fd_sc_hd__tapvpwrvgnd_1
XFILLER_99_478 VGND VGND VPWR VPWR sky130_fd_sc_hd__decap_3
XFILLER_101_428 VGND VGND VPWR VPWR sky130_fd_sc_hd__decap_3
XFILLER_86_128 VGND VGND VPWR VPWR sky130_fd_sc_hd__decap_3
XFILLER_87_629 VGND VGND VPWR VPWR sky130_fd_sc_hd__decap_3
XFILLER_67_320 VGND VGND VPWR VPWR sky130_fd_sc_hd__decap_3
X_4184_ _7296_/Q _4352_/A2 _4351_/A2 _7104_/Q _4183_/X VGND VGND VPWR VPWR _4185_/C
+ sky130_fd_sc_hd__a221o_2
XFILLER_55_526 VGND VGND VPWR VPWR sky130_fd_sc_hd__decap_3
XFILLER_82_301 VGND VGND VPWR VPWR sky130_fd_sc_hd__decap_3
XFILLER_103_27 VGND VGND VPWR VPWR sky130_fd_sc_hd__decap_3
XFILLER_82_312 VGND VGND VPWR VPWR sky130_fd_sc_hd__decap_3
XFILLER_94_172 VGND VGND VPWR VPWR sky130_fd_sc_hd__decap_3
XFILLER_42_209 VGND VGND VPWR VPWR sky130_fd_sc_hd__decap_3
XFILLER_70_518 VGND VGND VPWR VPWR sky130_fd_sc_hd__decap_3
XFILLER_70_529 VGND VGND VPWR VPWR sky130_fd_sc_hd__decap_3
XFILLER_82_389 VGND VGND VPWR VPWR sky130_fd_sc_hd__decap_3
XFILLER_50_242 VGND VGND VPWR VPWR sky130_fd_sc_hd__decap_3
X_6825_ _6958_/CLK _6825_/D VGND VGND VPWR VPWR _6825_/Q sky130_fd_sc_hd__dfxtp_2
XFILLER_10_106 VGND VGND VPWR VPWR sky130_fd_sc_hd__fill_2
XFILLER_11_629 VGND VGND VPWR VPWR sky130_fd_sc_hd__decap_3
XFILLER_23_478 VGND VGND VPWR VPWR sky130_fd_sc_hd__fill_1
X_6756_ _6976_/CLK _6756_/D VGND VGND VPWR VPWR _6756_/Q sky130_fd_sc_hd__dfxtp_2
X_3968_ _7356_/Q _4510_/A0 _3975_/S VGND VGND VPWR VPWR _7356_/D sky130_fd_sc_hd__mux2_2
XFILLER_10_128 VGND VGND VPWR VPWR sky130_fd_sc_hd__decap_3
X_6687_ clkload4/A _6687_/D VGND VGND VPWR VPWR _6687_/Q sky130_fd_sc_hd__dfxtp_2
X_3899_ _6693_/Q _5660_/B _3925_/B1 _6871_/Q _3746_/C VGND VGND VPWR VPWR _3899_/X
+ sky130_fd_sc_hd__a221o_2
X_5569_ hold951/X _4909_/A _4910_/B VGND VGND VPWR VPWR _7048_/D sky130_fd_sc_hd__a21bo_2
XFILLER_104_200 VGND VGND VPWR VPWR sky130_fd_sc_hd__decap_3
X_7308_ _7373_/CLK _7308_/D _6588_/Y VGND VGND VPWR VPWR _7308_/Q sky130_fd_sc_hd__dfrtp_2
XFILLER_2_349 VGND VGND VPWR VPWR sky130_fd_sc_hd__decap_3
XFILLER_104_288 VGND VGND VPWR VPWR sky130_fd_sc_hd__decap_3
XFILLER_77_128 VGND VGND VPWR VPWR sky130_fd_sc_hd__decap_3
XFILLER_78_629 VGND VGND VPWR VPWR sky130_fd_sc_hd__decap_3
X_7239_ _7405_/CLK _7239_/D _6519_/Y VGND VGND VPWR VPWR _7239_/Q sky130_fd_sc_hd__dfrtp_2
XFILLER_58_342 VGND VGND VPWR VPWR sky130_fd_sc_hd__decap_3
XFILLER_100_450 VGND VGND VPWR VPWR sky130_fd_sc_hd__decap_3
XFILLER_37_54 VGND VGND VPWR VPWR sky130_fd_sc_hd__fill_2
XFILLER_73_323 VGND VGND VPWR VPWR sky130_fd_sc_hd__decap_3
XFILLER_73_367 VGND VGND VPWR VPWR sky130_fd_sc_hd__decap_3
XTAP_TAPCELL_ROW_44_738 VGND VPWR sky130_fd_sc_hd__tapvpwrvgnd_1
XTAP_TAPCELL_ROW_16_418 VGND VPWR sky130_fd_sc_hd__tapvpwrvgnd_1
XFILLER_26_294 VGND VGND VPWR VPWR sky130_fd_sc_hd__decap_3
XFILLER_41_231 VGND VGND VPWR VPWR sky130_fd_sc_hd__fill_2
XFILLER_53_31 VGND VGND VPWR VPWR sky130_fd_sc_hd__fill_2
XFILLER_54_592 VGND VGND VPWR VPWR sky130_fd_sc_hd__decap_3
XFILLER_41_275 VGND VGND VPWR VPWR sky130_fd_sc_hd__decap_3
XFILLER_5_110 VGND VGND VPWR VPWR sky130_fd_sc_hd__fill_2
XFILLER_6_622 VGND VGND VPWR VPWR sky130_fd_sc_hd__decap_3
XFILLER_108_561 VGND VGND VPWR VPWR sky130_fd_sc_hd__decap_3
XFILLER_5_143 VGND VGND VPWR VPWR sky130_fd_sc_hd__decap_3
XFILLER_69_629 VGND VGND VPWR VPWR sky130_fd_sc_hd__decap_3
XFILLER_78_83 VGND VGND VPWR VPWR sky130_fd_sc_hd__fill_1
XFILLER_1_393 VGND VGND VPWR VPWR sky130_fd_sc_hd__fill_2
XFILLER_49_364 VGND VGND VPWR VPWR sky130_fd_sc_hd__decap_3
XFILLER_76_150 VGND VGND VPWR VPWR sky130_fd_sc_hd__fill_2
XFILLER_49_397 VGND VGND VPWR VPWR sky130_fd_sc_hd__decap_3
XFILLER_64_312 VGND VGND VPWR VPWR sky130_fd_sc_hd__decap_3
XFILLER_64_334 VGND VGND VPWR VPWR sky130_fd_sc_hd__decap_3
XFILLER_24_209 VGND VGND VPWR VPWR sky130_fd_sc_hd__decap_3
XFILLER_64_356 VGND VGND VPWR VPWR sky130_fd_sc_hd__decap_3
XFILLER_91_142 VGND VGND VPWR VPWR sky130_fd_sc_hd__decap_3
XFILLER_45_570 VGND VGND VPWR VPWR sky130_fd_sc_hd__decap_3
XFILLER_64_389 VGND VGND VPWR VPWR sky130_fd_sc_hd__decap_3
XFILLER_91_164 VGND VGND VPWR VPWR sky130_fd_sc_hd__decap_3
XFILLER_91_175 VGND VGND VPWR VPWR sky130_fd_sc_hd__decap_3
X_4940_ _4814_/A _4937_/Y _4939_/X VGND VGND VPWR VPWR _4940_/Y sky130_fd_sc_hd__o21ai_2
XFILLER_91_197 VGND VGND VPWR VPWR sky130_fd_sc_hd__decap_3
X_4871_ _4845_/A _4643_/Y _4841_/Y _4948_/A VGND VGND VPWR VPWR _4871_/Y sky130_fd_sc_hd__a31oi_2
XFILLER_32_242 VGND VGND VPWR VPWR sky130_fd_sc_hd__decap_3
XFILLER_32_253 VGND VGND VPWR VPWR sky130_fd_sc_hd__decap_3
X_6610_ _6645_/A VGND VGND VPWR VPWR _6610_/Y sky130_fd_sc_hd__inv_2
X_3822_ hold963/X _3857_/A2 _5010_/C VGND VGND VPWR VPWR _7389_/D sky130_fd_sc_hd__a21o_2
XFILLER_20_426 VGND VGND VPWR VPWR sky130_fd_sc_hd__decap_3
XFILLER_60_595 VGND VGND VPWR VPWR sky130_fd_sc_hd__fill_2
X_6541_ _6541_/A VGND VGND VPWR VPWR _6541_/Y sky130_fd_sc_hd__inv_2
X_3753_ _3682_/A _3752_/X _5104_/A VGND VGND VPWR VPWR _3753_/X sky130_fd_sc_hd__a21o_2
XFILLER_9_471 VGND VGND VPWR VPWR sky130_fd_sc_hd__decap_3
X_6472_ _6536_/A VGND VGND VPWR VPWR _6472_/Y sky130_fd_sc_hd__inv_2
X_3684_ _3684_/A1 _3857_/A2 _3683_/Y VGND VGND VPWR VPWR _7404_/D sky130_fd_sc_hd__a21bo_2
XTAP_TAPCELL_ROW_76_1106 VGND VPWR sky130_fd_sc_hd__tapvpwrvgnd_1
X_5423_ _5423_/A0 _5139_/X _5429_/S VGND VGND VPWR VPWR _7122_/D sky130_fd_sc_hd__mux2_2
X_5354_ _5354_/A0 _5139_/X _7412_/A VGND VGND VPWR VPWR _7154_/D sky130_fd_sc_hd__mux2_2
X_4305_ _7064_/Q _4305_/B VGND VGND VPWR VPWR _4364_/B sky130_fd_sc_hd__nor2_2
XFILLER_101_203 VGND VGND VPWR VPWR sky130_fd_sc_hd__decap_3
XFILLER_87_437 VGND VGND VPWR VPWR sky130_fd_sc_hd__decap_3
XFILLER_101_225 VGND VGND VPWR VPWR sky130_fd_sc_hd__decap_3
XFILLER_59_139 VGND VGND VPWR VPWR sky130_fd_sc_hd__decap_3
X_7024_ _7372_/CLK _7024_/D _6304_/Y VGND VGND VPWR VPWR _7024_/Q sky130_fd_sc_hd__dfrtp_2
X_4236_ _7163_/Q _4348_/A2 _4234_/X _4235_/X VGND VGND VPWR VPWR _4236_/X sky130_fd_sc_hd__a211o_2
XFILLER_101_258 VGND VGND VPWR VPWR sky130_fd_sc_hd__fill_1
X_4167_ _7393_/Q _4399_/A2 _4998_/S _7297_/Q _4166_/X VGND VGND VPWR VPWR _4167_/X
+ sky130_fd_sc_hd__a221o_2
XFILLER_55_334 VGND VGND VPWR VPWR sky130_fd_sc_hd__fill_2
XFILLER_67_161 VGND VGND VPWR VPWR sky130_fd_sc_hd__decap_3
XTAP_TAPCELL_ROW_87_1235 VGND VPWR sky130_fd_sc_hd__tapvpwrvgnd_1
X_4098_ _7333_/Q _3958_/S _4261_/A2 _7365_/Q _4347_/C1 VGND VGND VPWR VPWR _4098_/X
+ sky130_fd_sc_hd__a221o_2
XFILLER_70_304 VGND VGND VPWR VPWR sky130_fd_sc_hd__fill_1
XFILLER_36_592 VGND VGND VPWR VPWR sky130_fd_sc_hd__fill_2
XFILLER_70_337 VGND VGND VPWR VPWR sky130_fd_sc_hd__decap_3
XFILLER_70_359 VGND VGND VPWR VPWR sky130_fd_sc_hd__fill_1
XFILLER_82_197 VGND VGND VPWR VPWR sky130_fd_sc_hd__fill_1
XFILLER_23_253 VGND VGND VPWR VPWR sky130_fd_sc_hd__decap_3
XFILLER_90_29 VGND VGND VPWR VPWR sky130_fd_sc_hd__decap_3
X_6808_ _6965_/CLK _6808_/D VGND VGND VPWR VPWR _6808_/Q sky130_fd_sc_hd__dfxtp_2
XTAP_TAPCELL_ROW_41_708 VGND VPWR sky130_fd_sc_hd__tapvpwrvgnd_1
XFILLER_11_426 VGND VGND VPWR VPWR sky130_fd_sc_hd__decap_3
XFILLER_23_275 VGND VGND VPWR VPWR sky130_fd_sc_hd__fill_1
XFILLER_23_297 VGND VGND VPWR VPWR sky130_fd_sc_hd__decap_3
XFILLER_51_584 VGND VGND VPWR VPWR sky130_fd_sc_hd__decap_3
X_6739_ _6958_/CLK _6739_/D VGND VGND VPWR VPWR _6739_/Q sky130_fd_sc_hd__dfxtp_2
XTAP_TAPCELL_ROW_98_1364 VGND VPWR sky130_fd_sc_hd__tapvpwrvgnd_1
XTAP_TAPCELL_ROW_21_476 VGND VPWR sky130_fd_sc_hd__tapvpwrvgnd_1
XFILLER_3_603 VGND VGND VPWR VPWR sky130_fd_sc_hd__decap_3
XFILLER_3_647 VGND VGND VPWR VPWR sky130_fd_sc_hd__fill_1
XFILLER_2_168 VGND VGND VPWR VPWR sky130_fd_sc_hd__decap_3
XFILLER_58_150 VGND VGND VPWR VPWR sky130_fd_sc_hd__decap_3
XFILLER_65_109 VGND VGND VPWR VPWR sky130_fd_sc_hd__decap_3
XFILLER_19_548 VGND VGND VPWR VPWR sky130_fd_sc_hd__decap_3
XFILLER_46_312 VGND VGND VPWR VPWR sky130_fd_sc_hd__fill_2
XFILLER_46_323 VGND VGND VPWR VPWR sky130_fd_sc_hd__fill_2
XFILLER_58_172 VGND VGND VPWR VPWR sky130_fd_sc_hd__decap_3
XFILLER_0_27 VGND VGND VPWR VPWR sky130_fd_sc_hd__fill_1
XFILLER_0_38 VGND VGND VPWR VPWR sky130_fd_sc_hd__fill_2
XFILLER_46_345 VGND VGND VPWR VPWR sky130_fd_sc_hd__fill_2
XFILLER_27_570 VGND VGND VPWR VPWR sky130_fd_sc_hd__decap_3
XFILLER_61_304 VGND VGND VPWR VPWR sky130_fd_sc_hd__decap_3
XTAP_TAPCELL_ROW_57_885 VGND VPWR sky130_fd_sc_hd__tapvpwrvgnd_1
XTAP_TAPCELL_ROW_29_565 VGND VPWR sky130_fd_sc_hd__tapvpwrvgnd_1
XTAP_TAPCELL_ROW_107_1460 VGND VPWR sky130_fd_sc_hd__tapvpwrvgnd_1
XFILLER_64_85 VGND VGND VPWR VPWR sky130_fd_sc_hd__fill_1
XFILLER_14_242 VGND VGND VPWR VPWR sky130_fd_sc_hd__decap_3
XFILLER_42_562 VGND VGND VPWR VPWR sky130_fd_sc_hd__decap_3
XFILLER_14_286 VGND VGND VPWR VPWR sky130_fd_sc_hd__decap_3
XFILLER_9_47 VGND VGND VPWR VPWR sky130_fd_sc_hd__decap_3
XFILLER_6_463 VGND VGND VPWR VPWR sky130_fd_sc_hd__fill_1
Xhold909 _6712_/Q VGND VGND VPWR VPWR hold909/X sky130_fd_sc_hd__dlygate4sd3_1
XFILLER_108_380 VGND VGND VPWR VPWR sky130_fd_sc_hd__fill_1
XFILLER_89_60 VGND VGND VPWR VPWR sky130_fd_sc_hd__decap_3
XFILLER_69_415 VGND VGND VPWR VPWR sky130_fd_sc_hd__decap_3
X_5070_ _5073_/A _5050_/X _5053_/Y VGND VGND VPWR VPWR _5075_/A sky130_fd_sc_hd__o21a_2
XTAP_TAPCELL_ROW_71_1047 VGND VPWR sky130_fd_sc_hd__tapvpwrvgnd_1
XFILLER_29_3 VGND VGND VPWR VPWR sky130_fd_sc_hd__fill_2
XFILLER_96_256 VGND VGND VPWR VPWR sky130_fd_sc_hd__decap_3
XFILLER_49_172 VGND VGND VPWR VPWR sky130_fd_sc_hd__decap_3
XFILLER_65_632 VGND VGND VPWR VPWR sky130_fd_sc_hd__decap_3
XFILLER_77_470 VGND VGND VPWR VPWR sky130_fd_sc_hd__fill_1
XFILLER_52_315 VGND VGND VPWR VPWR sky130_fd_sc_hd__decap_3
XFILLER_64_175 VGND VGND VPWR VPWR sky130_fd_sc_hd__decap_3
XFILLER_80_613 VGND VGND VPWR VPWR sky130_fd_sc_hd__decap_3
XFILLER_92_462 VGND VGND VPWR VPWR sky130_fd_sc_hd__decap_3
XFILLER_92_484 VGND VGND VPWR VPWR sky130_fd_sc_hd__decap_3
XFILLER_18_581 VGND VGND VPWR VPWR sky130_fd_sc_hd__decap_3
XFILLER_18_592 VGND VGND VPWR VPWR sky130_fd_sc_hd__decap_3
X_4923_ _4920_/A _4922_/X _4969_/B VGND VGND VPWR VPWR _4923_/Y sky130_fd_sc_hd__o21ai_2
XFILLER_100_17 VGND VGND VPWR VPWR sky130_fd_sc_hd__decap_3
XFILLER_33_551 VGND VGND VPWR VPWR sky130_fd_sc_hd__decap_3
XFILLER_20_212 VGND VGND VPWR VPWR sky130_fd_sc_hd__decap_3
XFILLER_33_595 VGND VGND VPWR VPWR sky130_fd_sc_hd__decap_3
XFILLER_60_392 VGND VGND VPWR VPWR sky130_fd_sc_hd__decap_3
X_4854_ _4764_/B _4096_/A _4633_/A _5101_/A VGND VGND VPWR VPWR _4854_/X sky130_fd_sc_hd__o22a_2
XTAP_TAPCELL_ROW_82_1176 VGND VPWR sky130_fd_sc_hd__tapvpwrvgnd_1
X_4785_ _4785_/A _4811_/B VGND VGND VPWR VPWR _4795_/B sky130_fd_sc_hd__nand2_2
X_3805_ _6948_/Q _3884_/B1 _3883_/B1 _6960_/Q VGND VGND VPWR VPWR _3805_/X sky130_fd_sc_hd__a22o_2
X_6524_ _6524_/A VGND VGND VPWR VPWR _6524_/Y sky130_fd_sc_hd__inv_2
X_6455_ _6556_/A VGND VGND VPWR VPWR _6455_/Y sky130_fd_sc_hd__inv_2
X_6386_ _6613_/A VGND VGND VPWR VPWR _6386_/Y sky130_fd_sc_hd__inv_2
X_3598_ _3598_/A _3611_/B VGND VGND VPWR VPWR _4614_/B sky130_fd_sc_hd__nor2_2
XFILLER_0_617 VGND VGND VPWR VPWR sky130_fd_sc_hd__decap_3
XFILLER_87_212 VGND VGND VPWR VPWR sky130_fd_sc_hd__fill_1
XFILLER_102_523 VGND VGND VPWR VPWR sky130_fd_sc_hd__decap_3
XFILLER_102_545 VGND VGND VPWR VPWR sky130_fd_sc_hd__decap_3
X_5268_ hold997/X _5027_/X _5276_/S VGND VGND VPWR VPWR _7196_/D sky130_fd_sc_hd__mux2_2
XFILLER_47_109 VGND VGND VPWR VPWR sky130_fd_sc_hd__decap_3
X_7007_ _7373_/CLK _7007_/D _6287_/Y VGND VGND VPWR VPWR _7007_/Q sky130_fd_sc_hd__dfrtp_2
X_4219_ _7292_/Q _4352_/A2 _4352_/B1 _7164_/Q _4218_/X VGND VGND VPWR VPWR _4219_/X
+ sky130_fd_sc_hd__a221o_2
XFILLER_56_621 VGND VGND VPWR VPWR sky130_fd_sc_hd__decap_3
XFILLER_28_345 VGND VGND VPWR VPWR sky130_fd_sc_hd__decap_3
XFILLER_28_389 VGND VGND VPWR VPWR sky130_fd_sc_hd__decap_3
XFILLER_43_304 VGND VGND VPWR VPWR sky130_fd_sc_hd__decap_3
XFILLER_55_153 VGND VGND VPWR VPWR sky130_fd_sc_hd__decap_3
XFILLER_55_175 VGND VGND VPWR VPWR sky130_fd_sc_hd__decap_3
XFILLER_71_613 VGND VGND VPWR VPWR sky130_fd_sc_hd__decap_3
XFILLER_71_635 VGND VGND VPWR VPWR sky130_fd_sc_hd__decap_3
XFILLER_34_11 VGND VGND VPWR VPWR sky130_fd_sc_hd__fill_2
XFILLER_43_348 VGND VGND VPWR VPWR sky130_fd_sc_hd__decap_3
XTAP_TAPCELL_ROW_54_855 VGND VPWR sky130_fd_sc_hd__tapvpwrvgnd_1
XTAP_TAPCELL_ROW_26_535 VGND VPWR sky130_fd_sc_hd__tapvpwrvgnd_1
XFILLER_24_540 VGND VGND VPWR VPWR sky130_fd_sc_hd__decap_3
XFILLER_70_156 VGND VGND VPWR VPWR sky130_fd_sc_hd__decap_3
XFILLER_70_178 VGND VGND VPWR VPWR sky130_fd_sc_hd__decap_3
XFILLER_11_212 VGND VGND VPWR VPWR sky130_fd_sc_hd__decap_3
XFILLER_34_88 VGND VGND VPWR VPWR sky130_fd_sc_hd__decap_3
XFILLER_11_245 VGND VGND VPWR VPWR sky130_fd_sc_hd__decap_3
XFILLER_11_278 VGND VGND VPWR VPWR sky130_fd_sc_hd__fill_2
XFILLER_7_216 VGND VGND VPWR VPWR sky130_fd_sc_hd__decap_3
XFILLER_50_65 VGND VGND VPWR VPWR sky130_fd_sc_hd__decap_3
XFILLER_7_249 VGND VGND VPWR VPWR sky130_fd_sc_hd__decap_3
XFILLER_3_411 VGND VGND VPWR VPWR sky130_fd_sc_hd__decap_3
XFILLER_105_350 VGND VGND VPWR VPWR sky130_fd_sc_hd__decap_3
XFILLER_59_52 VGND VGND VPWR VPWR sky130_fd_sc_hd__decap_3
XFILLER_105_383 VGND VGND VPWR VPWR sky130_fd_sc_hd__decap_3
XFILLER_59_74 VGND VGND VPWR VPWR sky130_fd_sc_hd__fill_2
XFILLER_93_204 VGND VGND VPWR VPWR sky130_fd_sc_hd__decap_3
XFILLER_15_9 VGND VGND VPWR VPWR sky130_fd_sc_hd__fill_1
XFILLER_47_610 VGND VGND VPWR VPWR sky130_fd_sc_hd__decap_3
XFILLER_47_632 VGND VGND VPWR VPWR sky130_fd_sc_hd__decap_3
XFILLER_59_470 VGND VGND VPWR VPWR sky130_fd_sc_hd__decap_3
XFILLER_78_289 VGND VGND VPWR VPWR sky130_fd_sc_hd__fill_1
XFILLER_19_334 VGND VGND VPWR VPWR sky130_fd_sc_hd__fill_2
XFILLER_19_367 VGND VGND VPWR VPWR sky130_fd_sc_hd__decap_3
XFILLER_34_315 VGND VGND VPWR VPWR sky130_fd_sc_hd__decap_3
XFILLER_62_624 VGND VGND VPWR VPWR sky130_fd_sc_hd__decap_3
XFILLER_34_359 VGND VGND VPWR VPWR sky130_fd_sc_hd__decap_3
XFILLER_46_197 VGND VGND VPWR VPWR sky130_fd_sc_hd__fill_2
XFILLER_61_167 VGND VGND VPWR VPWR sky130_fd_sc_hd__fill_1
XFILLER_61_178 VGND VGND VPWR VPWR sky130_fd_sc_hd__fill_2
XFILLER_15_573 VGND VGND VPWR VPWR sky130_fd_sc_hd__decap_3
XFILLER_30_521 VGND VGND VPWR VPWR sky130_fd_sc_hd__decap_3
XFILLER_30_576 VGND VGND VPWR VPWR sky130_fd_sc_hd__decap_3
XFILLER_30_598 VGND VGND VPWR VPWR sky130_fd_sc_hd__decap_3
X_3521_ _3525_/A _3525_/B VGND VGND VPWR VPWR _3618_/C sky130_fd_sc_hd__nand2_2
Xhold706 _6888_/Q VGND VGND VPWR VPWR _6888_/D sky130_fd_sc_hd__dlygate4sd3_1
Xhold717 _6860_/Q VGND VGND VPWR VPWR _6860_/D sky130_fd_sc_hd__dlygate4sd3_1
Xhold728 _6768_/Q VGND VGND VPWR VPWR _6768_/D sky130_fd_sc_hd__dlygate4sd3_1
Xhold739 _6741_/Q VGND VGND VPWR VPWR _6741_/D sky130_fd_sc_hd__dlygate4sd3_1
X_3383_ _5118_/D _3383_/B VGND VGND VPWR VPWR _3562_/A sky130_fd_sc_hd__nor2_2
X_5122_ _5122_/A0 _5121_/X _5142_/S VGND VGND VPWR VPWR _7254_/D sky130_fd_sc_hd__mux2_2
XFILLER_97_532 VGND VGND VPWR VPWR sky130_fd_sc_hd__decap_3
XFILLER_69_256 VGND VGND VPWR VPWR sky130_fd_sc_hd__decap_3
XFILLER_69_267 VGND VGND VPWR VPWR sky130_fd_sc_hd__decap_3
XFILLER_97_576 VGND VGND VPWR VPWR sky130_fd_sc_hd__decap_3
XFILLER_38_621 VGND VGND VPWR VPWR sky130_fd_sc_hd__decap_3
X_5053_ _5073_/A _5050_/X _5020_/A VGND VGND VPWR VPWR _5053_/Y sky130_fd_sc_hd__a21oi_2
XFILLER_84_259 VGND VGND VPWR VPWR sky130_fd_sc_hd__decap_3
XFILLER_53_602 VGND VGND VPWR VPWR sky130_fd_sc_hd__decap_3
XFILLER_80_410 VGND VGND VPWR VPWR sky130_fd_sc_hd__fill_1
XTAP_TAPCELL_ROW_84_1205 VGND VPWR sky130_fd_sc_hd__tapvpwrvgnd_1
XFILLER_25_337 VGND VGND VPWR VPWR sky130_fd_sc_hd__decap_3
XFILLER_37_186 VGND VGND VPWR VPWR sky130_fd_sc_hd__decap_3
XFILLER_53_635 VGND VGND VPWR VPWR sky130_fd_sc_hd__decap_3
XFILLER_25_359 VGND VGND VPWR VPWR sky130_fd_sc_hd__decap_3
XFILLER_52_189 VGND VGND VPWR VPWR sky130_fd_sc_hd__decap_3
X_4906_ _4814_/A _4886_/C _4904_/X _4905_/X VGND VGND VPWR VPWR _4906_/X sky130_fd_sc_hd__o31a_2
XTAP_TAPCELL_ROW_51_825 VGND VPWR sky130_fd_sc_hd__tapvpwrvgnd_1
X_4837_ _4837_/A0 _4836_/X _4946_/S VGND VGND VPWR VPWR _7271_/D sky130_fd_sc_hd__mux2_2
X_4768_ _4762_/Y _4763_/X _4767_/X VGND VGND VPWR VPWR _4768_/Y sky130_fd_sc_hd__o21ai_2
XTAP_TAPCELL_ROW_31_593 VGND VPWR sky130_fd_sc_hd__tapvpwrvgnd_1
XFILLER_106_103 VGND VGND VPWR VPWR sky130_fd_sc_hd__decap_3
XFILLER_107_626 VGND VGND VPWR VPWR sky130_fd_sc_hd__decap_3
X_6507_ _6603_/A VGND VGND VPWR VPWR _6507_/Y sky130_fd_sc_hd__inv_2
X_4699_ _6986_/Q _6987_/Q _5098_/A VGND VGND VPWR VPWR _5066_/A sky130_fd_sc_hd__and3_2
XTAP_TAPCELL_ROW_95_1323 VGND VPWR sky130_fd_sc_hd__tapvpwrvgnd_1
XFILLER_20_57 VGND VGND VPWR VPWR sky130_fd_sc_hd__decap_3
X_6438_ _6628_/A VGND VGND VPWR VPWR _6438_/Y sky130_fd_sc_hd__inv_2
XFILLER_88_521 VGND VGND VPWR VPWR sky130_fd_sc_hd__decap_3
X_6369_ _6603_/A VGND VGND VPWR VPWR _6369_/Y sky130_fd_sc_hd__inv_2
XTAP_TAPCELL_ROW_59_914 VGND VPWR sky130_fd_sc_hd__tapvpwrvgnd_1
XFILLER_29_632 VGND VGND VPWR VPWR sky130_fd_sc_hd__decap_3
XFILLER_75_259 VGND VGND VPWR VPWR sky130_fd_sc_hd__decap_3
XFILLER_28_153 VGND VGND VPWR VPWR sky130_fd_sc_hd__decap_3
XFILLER_44_613 VGND VGND VPWR VPWR sky130_fd_sc_hd__decap_3
XFILLER_45_21 VGND VGND VPWR VPWR sky130_fd_sc_hd__fill_2
XFILLER_90_229 VGND VGND VPWR VPWR sky130_fd_sc_hd__decap_3
XTAP_TAPCELL_ROW_3_274 VGND VPWR sky130_fd_sc_hd__tapvpwrvgnd_1
XFILLER_28_197 VGND VGND VPWR VPWR sky130_fd_sc_hd__fill_1
XFILLER_43_134 VGND VGND VPWR VPWR sky130_fd_sc_hd__fill_1
XFILLER_83_281 VGND VGND VPWR VPWR sky130_fd_sc_hd__decap_3
XTAP_TAPCELL_ROW_39_682 VGND VPWR sky130_fd_sc_hd__tapvpwrvgnd_1
XFILLER_16_359 VGND VGND VPWR VPWR sky130_fd_sc_hd__decap_3
XFILLER_71_476 VGND VGND VPWR VPWR sky130_fd_sc_hd__decap_3
XTAP_TAPCELL_ROW_104_1430 VGND VPWR sky130_fd_sc_hd__tapvpwrvgnd_1
XFILLER_24_381 VGND VGND VPWR VPWR sky130_fd_sc_hd__fill_1
XFILLER_8_503 VGND VGND VPWR VPWR sky130_fd_sc_hd__fill_1
XFILLER_12_576 VGND VGND VPWR VPWR sky130_fd_sc_hd__decap_3
XFILLER_12_598 VGND VGND VPWR VPWR sky130_fd_sc_hd__decap_3
XFILLER_8_525 VGND VGND VPWR VPWR sky130_fd_sc_hd__decap_3
XFILLER_8_536 VGND VGND VPWR VPWR sky130_fd_sc_hd__decap_3
XANTENNA_8 _7370_/Q VGND VGND VPWR VPWR sky130_fd_sc_hd__diode_2
XFILLER_3_274 VGND VGND VPWR VPWR sky130_fd_sc_hd__decap_3
XFILLER_79_532 VGND VGND VPWR VPWR sky130_fd_sc_hd__decap_3
XFILLER_94_502 VGND VGND VPWR VPWR sky130_fd_sc_hd__decap_3
XFILLER_66_226 VGND VGND VPWR VPWR sky130_fd_sc_hd__decap_3
XFILLER_19_131 VGND VGND VPWR VPWR sky130_fd_sc_hd__decap_3
XFILLER_94_557 VGND VGND VPWR VPWR sky130_fd_sc_hd__decap_3
XFILLER_19_164 VGND VGND VPWR VPWR sky130_fd_sc_hd__decap_3
XFILLER_19_197 VGND VGND VPWR VPWR sky130_fd_sc_hd__decap_3
XFILLER_35_635 VGND VGND VPWR VPWR sky130_fd_sc_hd__decap_3
XFILLER_47_495 VGND VGND VPWR VPWR sky130_fd_sc_hd__decap_3
XFILLER_34_156 VGND VGND VPWR VPWR sky130_fd_sc_hd__decap_3
XFILLER_50_605 VGND VGND VPWR VPWR sky130_fd_sc_hd__decap_3
XFILLER_62_454 VGND VGND VPWR VPWR sky130_fd_sc_hd__decap_3
XFILLER_34_178 VGND VGND VPWR VPWR sky130_fd_sc_hd__fill_2
XFILLER_50_638 VGND VGND VPWR VPWR sky130_fd_sc_hd__decap_3
XFILLER_62_498 VGND VGND VPWR VPWR sky130_fd_sc_hd__decap_3
X_5671_ _5671_/A _5671_/B VGND VGND VPWR VPWR _6983_/D sky130_fd_sc_hd__and2_2
X_4622_ _5072_/B _4621_/X _5071_/B VGND VGND VPWR VPWR _4622_/X sky130_fd_sc_hd__a21bo_2
X_7341_ _7373_/CLK _7341_/D _6621_/Y VGND VGND VPWR VPWR _7341_/Q sky130_fd_sc_hd__dfrtp_2
XFILLER_7_591 VGND VGND VPWR VPWR sky130_fd_sc_hd__decap_3
X_7272_ _7372_/CLK _7272_/D _6552_/Y VGND VGND VPWR VPWR _7272_/Q sky130_fd_sc_hd__dfrtp_2
X_4484_ _4484_/A0 _7305_/Q _4488_/S VGND VGND VPWR VPWR _7337_/D sky130_fd_sc_hd__mux2_2
X_3504_ _3501_/X _3502_/X _3630_/A VGND VGND VPWR VPWR _3505_/B sky130_fd_sc_hd__a21oi_2
XFILLER_104_629 VGND VGND VPWR VPWR sky130_fd_sc_hd__decap_3
XFILLER_106_38 VGND VGND VPWR VPWR sky130_fd_sc_hd__decap_3
X_3366_ _3376_/A _3376_/B _3399_/B _5118_/A VGND VGND VPWR VPWR _3366_/X sky130_fd_sc_hd__o211a_2
XTAP_TAPCELL_ROW_90_1275 VGND VPWR sky130_fd_sc_hd__tapvpwrvgnd_1
XTAP_TAPCELL_ROW_90_1264 VGND VPWR sky130_fd_sc_hd__tapvpwrvgnd_1
XFILLER_97_340 VGND VGND VPWR VPWR sky130_fd_sc_hd__decap_3
XFILLER_85_535 VGND VGND VPWR VPWR sky130_fd_sc_hd__decap_3
Xhold1203 _7119_/Q VGND VGND VPWR VPWR _5429_/A0 sky130_fd_sc_hd__dlygate4sd3_1
Xhold1214 _7009_/Q VGND VGND VPWR VPWR _7009_/D sky130_fd_sc_hd__dlygate4sd3_1
X_5105_ _4467_/B _3874_/X _5104_/Y _5666_/A VGND VGND VPWR VPWR _5105_/X sky130_fd_sc_hd__a31o_2
XFILLER_97_384 VGND VGND VPWR VPWR sky130_fd_sc_hd__fill_2
XFILLER_57_237 VGND VGND VPWR VPWR sky130_fd_sc_hd__fill_1
X_5036_ _5036_/A _4674_/X VGND VGND VPWR VPWR _5038_/A sky130_fd_sc_hd__or2b_2
XFILLER_26_602 VGND VGND VPWR VPWR sky130_fd_sc_hd__decap_3
XFILLER_72_218 VGND VGND VPWR VPWR sky130_fd_sc_hd__decap_3
XFILLER_26_635 VGND VGND VPWR VPWR sky130_fd_sc_hd__decap_3
XFILLER_65_281 VGND VGND VPWR VPWR sky130_fd_sc_hd__decap_3
XTAP_TAPCELL_ROW_0_233 VGND VPWR sky130_fd_sc_hd__tapvpwrvgnd_1
XTAP_TAPCELL_ROW_0_222 VGND VPWR sky130_fd_sc_hd__tapvpwrvgnd_1
XFILLER_13_307 VGND VGND VPWR VPWR sky130_fd_sc_hd__decap_3
XFILLER_80_240 VGND VGND VPWR VPWR sky130_fd_sc_hd__fill_2
X_6987_ _7398_/CLK _6987_/D _6267_/Y VGND VGND VPWR VPWR _6987_/Q sky130_fd_sc_hd__dfrtp_2
XTAP_TAPCELL_ROW_64_972 VGND VPWR sky130_fd_sc_hd__tapvpwrvgnd_1
XTAP_TAPCELL_ROW_36_652 VGND VPWR sky130_fd_sc_hd__tapvpwrvgnd_1
XFILLER_15_57 VGND VGND VPWR VPWR sky130_fd_sc_hd__decap_3
XFILLER_25_178 VGND VGND VPWR VPWR sky130_fd_sc_hd__decap_3
XFILLER_41_638 VGND VGND VPWR VPWR sky130_fd_sc_hd__decap_3
XFILLER_15_68 VGND VGND VPWR VPWR sky130_fd_sc_hd__decap_3
XFILLER_15_79 VGND VGND VPWR VPWR sky130_fd_sc_hd__decap_3
XFILLER_21_384 VGND VGND VPWR VPWR sky130_fd_sc_hd__decap_3
XFILLER_107_434 VGND VGND VPWR VPWR sky130_fd_sc_hd__decap_3
XFILLER_0_211 VGND VGND VPWR VPWR sky130_fd_sc_hd__fill_2
XTAP_TAPCELL_ROW_8_322 VGND VPWR sky130_fd_sc_hd__tapvpwrvgnd_1
XFILLER_88_351 VGND VGND VPWR VPWR sky130_fd_sc_hd__fill_1
XFILLER_102_150 VGND VGND VPWR VPWR sky130_fd_sc_hd__decap_3
XFILLER_48_215 VGND VGND VPWR VPWR sky130_fd_sc_hd__decap_3
XFILLER_76_513 VGND VGND VPWR VPWR sky130_fd_sc_hd__decap_3
XFILLER_88_384 VGND VGND VPWR VPWR sky130_fd_sc_hd__decap_3
XFILLER_0_299 VGND VGND VPWR VPWR sky130_fd_sc_hd__decap_3
XFILLER_48_259 VGND VGND VPWR VPWR sky130_fd_sc_hd__decap_3
XFILLER_56_53 VGND VGND VPWR VPWR sky130_fd_sc_hd__decap_3
XFILLER_63_207 VGND VGND VPWR VPWR sky130_fd_sc_hd__decap_3
XFILLER_91_505 VGND VGND VPWR VPWR sky130_fd_sc_hd__decap_3
XFILLER_17_635 VGND VGND VPWR VPWR sky130_fd_sc_hd__decap_3
XFILLER_44_421 VGND VGND VPWR VPWR sky130_fd_sc_hd__fill_1
XFILLER_56_292 VGND VGND VPWR VPWR sky130_fd_sc_hd__fill_2
XFILLER_32_616 VGND VGND VPWR VPWR sky130_fd_sc_hd__decap_3
XFILLER_44_498 VGND VGND VPWR VPWR sky130_fd_sc_hd__decap_3
XFILLER_31_148 VGND VGND VPWR VPWR sky130_fd_sc_hd__decap_3
XFILLER_12_351 VGND VGND VPWR VPWR sky130_fd_sc_hd__decap_3
XFILLER_82_9 VGND VGND VPWR VPWR sky130_fd_sc_hd__fill_1
XFILLER_12_373 VGND VGND VPWR VPWR sky130_fd_sc_hd__fill_1
XFILLER_12_384 VGND VGND VPWR VPWR sky130_fd_sc_hd__decap_3
XFILLER_8_333 VGND VGND VPWR VPWR sky130_fd_sc_hd__decap_3
XFILLER_8_355 VGND VGND VPWR VPWR sky130_fd_sc_hd__fill_2
XFILLER_4_572 VGND VGND VPWR VPWR sky130_fd_sc_hd__decap_3
XFILLER_99_638 VGND VGND VPWR VPWR sky130_fd_sc_hd__decap_3
XFILLER_79_340 VGND VGND VPWR VPWR sky130_fd_sc_hd__decap_3
XFILLER_79_384 VGND VGND VPWR VPWR sky130_fd_sc_hd__decap_3
XFILLER_11_3 VGND VGND VPWR VPWR sky130_fd_sc_hd__decap_3
XFILLER_94_321 VGND VGND VPWR VPWR sky130_fd_sc_hd__decap_3
XFILLER_82_527 VGND VGND VPWR VPWR sky130_fd_sc_hd__decap_3
XFILLER_94_354 VGND VGND VPWR VPWR sky130_fd_sc_hd__fill_2
XTAP_TAPCELL_ROW_68_1019 VGND VPWR sky130_fd_sc_hd__tapvpwrvgnd_1
XFILLER_35_421 VGND VGND VPWR VPWR sky130_fd_sc_hd__decap_3
XFILLER_47_281 VGND VGND VPWR VPWR sky130_fd_sc_hd__decap_3
X_6910_ _6974_/CLK _6910_/D VGND VGND VPWR VPWR _6910_/Q sky130_fd_sc_hd__dfxtp_2
X_6841_ _6963_/CLK _6841_/D VGND VGND VPWR VPWR _6841_/Q sky130_fd_sc_hd__dfxtp_2
XFILLER_23_638 VGND VGND VPWR VPWR sky130_fd_sc_hd__decap_3
XTAP_TAPCELL_ROW_33_611 VGND VPWR sky130_fd_sc_hd__tapvpwrvgnd_1
X_6772_ _6976_/CLK _6772_/D VGND VGND VPWR VPWR _6772_/Q sky130_fd_sc_hd__dfxtp_2
XTAP_TAPCELL_ROW_61_931 VGND VPWR sky130_fd_sc_hd__tapvpwrvgnd_1
X_5723_ _7367_/Q hold921/X _5737_/S VGND VGND VPWR VPWR _6711_/D sky130_fd_sc_hd__mux2_2
X_5654_ _5665_/A VGND VGND VPWR VPWR _5654_/Y sky130_fd_sc_hd__inv_2
XTAP_TAPCELL_ROW_79_1148 VGND VPWR sky130_fd_sc_hd__tapvpwrvgnd_1
X_7324_ _7356_/CLK _7324_/D _6604_/Y VGND VGND VPWR VPWR _7324_/Q sky130_fd_sc_hd__dfrtp_2
X_5585_ hold945/X _5587_/B _5106_/X VGND VGND VPWR VPWR _7036_/D sky130_fd_sc_hd__a21o_2
X_4536_ hold937/X _3398_/Y _3488_/X VGND VGND VPWR VPWR _7311_/D sky130_fd_sc_hd__a21o_2
X_7255_ _7376_/CLK _7255_/D _6535_/Y VGND VGND VPWR VPWR _7255_/Q sky130_fd_sc_hd__dfrtp_2
X_4467_ _4467_/A _4467_/B VGND VGND VPWR VPWR _4467_/Y sky130_fd_sc_hd__nor2_2
XFILLER_104_459 VGND VGND VPWR VPWR sky130_fd_sc_hd__decap_3
X_7186_ _7355_/CLK _7186_/D _6466_/Y VGND VGND VPWR VPWR _7186_/Q sky130_fd_sc_hd__dfrtp_2
X_4398_ _7338_/Q _3943_/S _4478_/S _7306_/Q VGND VGND VPWR VPWR _4398_/X sky130_fd_sc_hd__a22o_2
X_3418_ _7283_/Q _5132_/S _3417_/X _7091_/Q VGND VGND VPWR VPWR _3418_/X sky130_fd_sc_hd__a22o_2
XFILLER_58_502 VGND VGND VPWR VPWR sky130_fd_sc_hd__fill_2
Xhold1000 _7186_/Q VGND VGND VPWR VPWR _5286_/A0 sky130_fd_sc_hd__dlygate4sd3_1
X_3349_ _3561_/A _5294_/A VGND VGND VPWR VPWR _3350_/B sky130_fd_sc_hd__nand2_2
XFILLER_85_321 VGND VGND VPWR VPWR sky130_fd_sc_hd__decap_3
Xhold1011 _7202_/Q VGND VGND VPWR VPWR _5256_/A0 sky130_fd_sc_hd__dlygate4sd3_1
Xhold1022 _7393_/Q VGND VGND VPWR VPWR _3770_/A1 sky130_fd_sc_hd__dlygate4sd3_1
Xhold1033 _7266_/Q VGND VGND VPWR VPWR _4933_/A0 sky130_fd_sc_hd__dlygate4sd3_1
XFILLER_97_181 VGND VGND VPWR VPWR sky130_fd_sc_hd__decap_3
XFILLER_45_218 VGND VGND VPWR VPWR sky130_fd_sc_hd__decap_3
XFILLER_73_505 VGND VGND VPWR VPWR sky130_fd_sc_hd__fill_1
XFILLER_73_516 VGND VGND VPWR VPWR sky130_fd_sc_hd__decap_3
XFILLER_85_376 VGND VGND VPWR VPWR sky130_fd_sc_hd__fill_1
Xhold1044 _7241_/Q VGND VGND VPWR VPWR _5173_/A sky130_fd_sc_hd__dlygate4sd3_1
Xhold1055 _7213_/Q VGND VGND VPWR VPWR _5234_/A0 sky130_fd_sc_hd__dlygate4sd3_1
Xhold1066 _7236_/Q VGND VGND VPWR VPWR _5184_/A sky130_fd_sc_hd__dlygate4sd3_1
Xhold1077 _6695_/Q VGND VGND VPWR VPWR _5690_/A1 sky130_fd_sc_hd__dlygate4sd3_1
Xhold1088 _7281_/Q VGND VGND VPWR VPWR _4599_/A0 sky130_fd_sc_hd__dlygate4sd3_1
Xhold1099 _7019_/Q VGND VGND VPWR VPWR _5617_/A sky130_fd_sc_hd__dlygate4sd3_1
X_5019_ _4243_/Y _5032_/B _4989_/X _5018_/Y VGND VGND VPWR VPWR _5020_/B sky130_fd_sc_hd__a22o_2
XFILLER_38_292 VGND VGND VPWR VPWR sky130_fd_sc_hd__fill_2
XFILLER_53_240 VGND VGND VPWR VPWR sky130_fd_sc_hd__decap_3
XFILLER_14_616 VGND VGND VPWR VPWR sky130_fd_sc_hd__decap_3
XFILLER_81_571 VGND VGND VPWR VPWR sky130_fd_sc_hd__fill_1
XFILLER_13_148 VGND VGND VPWR VPWR sky130_fd_sc_hd__decap_3
XFILLER_41_446 VGND VGND VPWR VPWR sky130_fd_sc_hd__fill_2
XTAP_TAPCELL_ROW_101_1400 VGND VPWR sky130_fd_sc_hd__tapvpwrvgnd_1
XFILLER_21_192 VGND VGND VPWR VPWR sky130_fd_sc_hd__decap_3
XFILLER_1_520 VGND VGND VPWR VPWR sky130_fd_sc_hd__decap_3
XFILLER_1_553 VGND VGND VPWR VPWR sky130_fd_sc_hd__decap_3
XFILLER_107_81 VGND VGND VPWR VPWR sky130_fd_sc_hd__decap_3
XFILLER_1_564 VGND VGND VPWR VPWR sky130_fd_sc_hd__decap_3
XFILLER_49_513 VGND VGND VPWR VPWR sky130_fd_sc_hd__decap_3
XFILLER_76_343 VGND VGND VPWR VPWR sky130_fd_sc_hd__decap_3
XFILLER_88_181 VGND VGND VPWR VPWR sky130_fd_sc_hd__decap_3
XFILLER_76_365 VGND VGND VPWR VPWR sky130_fd_sc_hd__decap_3
XFILLER_36_218 VGND VGND VPWR VPWR sky130_fd_sc_hd__decap_3
XFILLER_76_398 VGND VGND VPWR VPWR sky130_fd_sc_hd__decap_3
XFILLER_91_368 VGND VGND VPWR VPWR sky130_fd_sc_hd__decap_3
XTAP_TAPCELL_ROW_19_449 VGND VPWR sky130_fd_sc_hd__tapvpwrvgnd_1
XFILLER_44_262 VGND VGND VPWR VPWR sky130_fd_sc_hd__decap_3
XFILLER_20_619 VGND VGND VPWR VPWR sky130_fd_sc_hd__decap_3
XFILLER_32_468 VGND VGND VPWR VPWR sky130_fd_sc_hd__decap_3
XFILLER_9_620 VGND VGND VPWR VPWR sky130_fd_sc_hd__decap_3
XFILLER_8_141 VGND VGND VPWR VPWR sky130_fd_sc_hd__decap_3
X_4321_ _7098_/Q _4335_/B1 _4351_/B1 _7130_/Q VGND VGND VPWR VPWR _4321_/X sky130_fd_sc_hd__a22o_2
X_7040_ _7387_/CLK _7040_/D _6320_/Y VGND VGND VPWR VPWR _7040_/Q sky130_fd_sc_hd__dfrtp_2
X_4252_ _7197_/Q _3966_/S _4272_/B _7357_/Q VGND VGND VPWR VPWR _4252_/X sky130_fd_sc_hd__a22o_2
XFILLER_101_407 VGND VGND VPWR VPWR sky130_fd_sc_hd__decap_3
XTAP_TAPCELL_ROW_74_1089 VGND VPWR sky130_fd_sc_hd__tapvpwrvgnd_1
XFILLER_79_181 VGND VGND VPWR VPWR sky130_fd_sc_hd__decap_3
X_4183_ _7360_/Q _4270_/B _4352_/B1 _7168_/Q _4182_/X VGND VGND VPWR VPWR _4183_/X
+ sky130_fd_sc_hd__a221o_2
XFILLER_95_630 VGND VGND VPWR VPWR sky130_fd_sc_hd__decap_3
XFILLER_55_505 VGND VGND VPWR VPWR sky130_fd_sc_hd__decap_3
XFILLER_94_151 VGND VGND VPWR VPWR sky130_fd_sc_hd__fill_1
XFILLER_94_162 VGND VGND VPWR VPWR sky130_fd_sc_hd__decap_3
XFILLER_27_218 VGND VGND VPWR VPWR sky130_fd_sc_hd__decap_3
XFILLER_55_538 VGND VGND VPWR VPWR sky130_fd_sc_hd__fill_1
XFILLER_82_324 VGND VGND VPWR VPWR sky130_fd_sc_hd__fill_2
XFILLER_94_184 VGND VGND VPWR VPWR sky130_fd_sc_hd__fill_2
XFILLER_23_402 VGND VGND VPWR VPWR sky130_fd_sc_hd__decap_3
XFILLER_35_273 VGND VGND VPWR VPWR sky130_fd_sc_hd__decap_3
XFILLER_23_424 VGND VGND VPWR VPWR sky130_fd_sc_hd__fill_2
XFILLER_23_435 VGND VGND VPWR VPWR sky130_fd_sc_hd__fill_2
X_6824_ _6966_/CLK _6824_/D VGND VGND VPWR VPWR _6824_/Q sky130_fd_sc_hd__dfxtp_2
X_6755_ clkload5/A _6755_/D VGND VGND VPWR VPWR _6755_/Q sky130_fd_sc_hd__dfxtp_2
X_5706_ _5706_/A0 _6703_/Q _5708_/S VGND VGND VPWR VPWR _6703_/D sky130_fd_sc_hd__mux2_2
Xclkbuf_leaf_30_clk clkload0/A VGND VGND VPWR VPWR _7357_/CLK sky130_fd_sc_hd__clkbuf_16
X_6686_ _6686_/A VGND VGND VPWR VPWR _6686_/Y sky130_fd_sc_hd__inv_2
X_3898_ _6919_/Q _3926_/A2 _3926_/B1 _6783_/Q VGND VGND VPWR VPWR _3898_/X sky130_fd_sc_hd__a22o_2
XFILLER_12_58 VGND VGND VPWR VPWR sky130_fd_sc_hd__decap_3
X_5568_ hold950/X _4909_/A _4897_/X VGND VGND VPWR VPWR _7049_/D sky130_fd_sc_hd__a21o_2
X_7307_ _7373_/CLK _7307_/D _6587_/Y VGND VGND VPWR VPWR _7307_/Q sky130_fd_sc_hd__dfrtp_2
X_4519_ hold965/X _3398_/Y _4300_/X VGND VGND VPWR VPWR _7320_/D sky130_fd_sc_hd__a21o_2
XFILLER_104_234 VGND VGND VPWR VPWR sky130_fd_sc_hd__decap_3
X_7238_ _7366_/CLK _7238_/D _6518_/Y VGND VGND VPWR VPWR _7238_/Q sky130_fd_sc_hd__dfrtp_2
X_7169_ _7361_/CLK _7169_/D _6449_/Y VGND VGND VPWR VPWR _7169_/Q sky130_fd_sc_hd__dfrtp_2
XFILLER_58_365 VGND VGND VPWR VPWR sky130_fd_sc_hd__decap_3
XFILLER_85_151 VGND VGND VPWR VPWR sky130_fd_sc_hd__decap_3
XFILLER_18_218 VGND VGND VPWR VPWR sky130_fd_sc_hd__decap_3
XFILLER_37_66 VGND VGND VPWR VPWR sky130_fd_sc_hd__decap_3
XFILLER_46_549 VGND VGND VPWR VPWR sky130_fd_sc_hd__decap_3
XFILLER_73_335 VGND VGND VPWR VPWR sky130_fd_sc_hd__fill_1
XFILLER_61_508 VGND VGND VPWR VPWR sky130_fd_sc_hd__decap_3
XFILLER_73_346 VGND VGND VPWR VPWR sky130_fd_sc_hd__decap_3
XFILLER_14_402 VGND VGND VPWR VPWR sky130_fd_sc_hd__decap_3
XFILLER_14_413 VGND VGND VPWR VPWR sky130_fd_sc_hd__decap_3
XFILLER_26_262 VGND VGND VPWR VPWR sky130_fd_sc_hd__decap_3
XFILLER_54_582 VGND VGND VPWR VPWR sky130_fd_sc_hd__decap_3
XFILLER_73_379 VGND VGND VPWR VPWR sky130_fd_sc_hd__decap_3
XTAP_TAPCELL_ROW_44_739 VGND VPWR sky130_fd_sc_hd__tapvpwrvgnd_1
XTAP_TAPCELL_ROW_16_419 VGND VPWR sky130_fd_sc_hd__tapvpwrvgnd_1
XFILLER_26_284 VGND VGND VPWR VPWR sky130_fd_sc_hd__decap_3
XFILLER_81_390 VGND VGND VPWR VPWR sky130_fd_sc_hd__fill_2
XFILLER_53_87 VGND VGND VPWR VPWR sky130_fd_sc_hd__fill_1
XFILLER_6_601 VGND VGND VPWR VPWR sky130_fd_sc_hd__decap_3
Xclkbuf_leaf_21_clk clkload2/A VGND VGND VPWR VPWR _7276_/CLK sky130_fd_sc_hd__clkbuf_16
XFILLER_6_634 VGND VGND VPWR VPWR sky130_fd_sc_hd__decap_3
XFILLER_6_645 VGND VGND VPWR VPWR sky130_fd_sc_hd__decap_3
XFILLER_108_584 VGND VGND VPWR VPWR sky130_fd_sc_hd__decap_3
XFILLER_108_595 VGND VGND VPWR VPWR sky130_fd_sc_hd__fill_2
XFILLER_45_9 VGND VGND VPWR VPWR sky130_fd_sc_hd__decap_3
XFILLER_1_361 VGND VGND VPWR VPWR sky130_fd_sc_hd__fill_2
XFILLER_77_641 VGND VGND VPWR VPWR sky130_fd_sc_hd__decap_3
XFILLER_37_527 VGND VGND VPWR VPWR sky130_fd_sc_hd__decap_3
XFILLER_76_195 VGND VGND VPWR VPWR sky130_fd_sc_hd__fill_1
XFILLER_91_154 VGND VGND VPWR VPWR sky130_fd_sc_hd__fill_2
XFILLER_17_240 VGND VGND VPWR VPWR sky130_fd_sc_hd__decap_3
XFILLER_52_519 VGND VGND VPWR VPWR sky130_fd_sc_hd__fill_2
XFILLER_17_284 VGND VGND VPWR VPWR sky130_fd_sc_hd__fill_2
XFILLER_17_295 VGND VGND VPWR VPWR sky130_fd_sc_hd__decap_3
XFILLER_32_221 VGND VGND VPWR VPWR sky130_fd_sc_hd__decap_3
X_4870_ _4870_/A _4870_/B VGND VGND VPWR VPWR _4870_/Y sky130_fd_sc_hd__nor2_2
XFILLER_60_552 VGND VGND VPWR VPWR sky130_fd_sc_hd__decap_3
X_3821_ _3746_/C _3819_/X _3820_/X _3867_/B1 VGND VGND VPWR VPWR _5010_/C sky130_fd_sc_hd__o31a_2
XFILLER_20_438 VGND VGND VPWR VPWR sky130_fd_sc_hd__fill_1
XFILLER_32_287 VGND VGND VPWR VPWR sky130_fd_sc_hd__decap_3
X_6540_ _6637_/A VGND VGND VPWR VPWR _6540_/Y sky130_fd_sc_hd__inv_2
Xclkbuf_leaf_12_clk clkbuf_leaf_9_clk/A VGND VGND VPWR VPWR _6965_/CLK sky130_fd_sc_hd__clkbuf_16
X_3752_ _6799_/Q _3913_/A2 _3823_/A2 _6709_/Q _3751_/X VGND VGND VPWR VPWR _3752_/X
+ sky130_fd_sc_hd__a221o_2
X_6471_ _6536_/A VGND VGND VPWR VPWR _6471_/Y sky130_fd_sc_hd__inv_2
X_3683_ _3672_/X _3673_/X _3867_/B1 _3682_/Y VGND VGND VPWR VPWR _3683_/Y sky130_fd_sc_hd__o211ai_2
XFILLER_9_494 VGND VGND VPWR VPWR sky130_fd_sc_hd__decap_3
XTAP_TAPCELL_ROW_76_1107 VGND VPWR sky130_fd_sc_hd__tapvpwrvgnd_1
X_4304_ _7256_/Q _4601_/S _4303_/X VGND VGND VPWR VPWR _4364_/A sky130_fd_sc_hd__a21oi_2
XFILLER_99_221 VGND VGND VPWR VPWR sky130_fd_sc_hd__decap_3
XFILLER_87_405 VGND VGND VPWR VPWR sky130_fd_sc_hd__decap_3
X_5284_ hold991/X _5135_/X _5292_/S VGND VGND VPWR VPWR _7187_/D sky130_fd_sc_hd__mux2_2
XFILLER_99_287 VGND VGND VPWR VPWR sky130_fd_sc_hd__fill_2
XFILLER_99_276 VGND VGND VPWR VPWR sky130_fd_sc_hd__decap_3
XFILLER_101_215 VGND VGND VPWR VPWR sky130_fd_sc_hd__decap_3
XFILLER_101_237 VGND VGND VPWR VPWR sky130_fd_sc_hd__decap_3
XFILLER_59_129 VGND VGND VPWR VPWR sky130_fd_sc_hd__fill_2
XFILLER_68_630 VGND VGND VPWR VPWR sky130_fd_sc_hd__decap_3
X_7023_ _7372_/CLK _7023_/D _6303_/Y VGND VGND VPWR VPWR _7023_/Q sky130_fd_sc_hd__dfrtp_2
X_4235_ _7227_/Q _3377_/X _4348_/B1 _7131_/Q VGND VGND VPWR VPWR _4235_/X sky130_fd_sc_hd__a22o_2
XFILLER_99_298 VGND VGND VPWR VPWR sky130_fd_sc_hd__decap_3
XFILLER_67_140 VGND VGND VPWR VPWR sky130_fd_sc_hd__decap_3
X_4166_ _7233_/Q _4433_/B _3956_/S _7201_/Q VGND VGND VPWR VPWR _4166_/X sky130_fd_sc_hd__a22o_2
XFILLER_55_302 VGND VGND VPWR VPWR sky130_fd_sc_hd__decap_3
XFILLER_67_184 VGND VGND VPWR VPWR sky130_fd_sc_hd__decap_3
XFILLER_55_346 VGND VGND VPWR VPWR sky130_fd_sc_hd__decap_3
XFILLER_55_368 VGND VGND VPWR VPWR sky130_fd_sc_hd__decap_3
XTAP_TAPCELL_ROW_87_1236 VGND VPWR sky130_fd_sc_hd__tapvpwrvgnd_1
XFILLER_36_560 VGND VGND VPWR VPWR sky130_fd_sc_hd__decap_3
XFILLER_23_232 VGND VGND VPWR VPWR sky130_fd_sc_hd__decap_3
XFILLER_23_265 VGND VGND VPWR VPWR sky130_fd_sc_hd__decap_3
XFILLER_51_552 VGND VGND VPWR VPWR sky130_fd_sc_hd__decap_3
Xplace390 _5628_/B VGND VGND VPWR VPWR place390/X sky130_fd_sc_hd__buf_2
X_6807_ _6943_/CLK _6807_/D VGND VGND VPWR VPWR _6807_/Q sky130_fd_sc_hd__dfxtp_2
XTAP_TAPCELL_ROW_41_709 VGND VPWR sky130_fd_sc_hd__tapvpwrvgnd_1
XFILLER_11_449 VGND VGND VPWR VPWR sky130_fd_sc_hd__decap_3
X_6738_ clkload7/A _6738_/D VGND VGND VPWR VPWR _6738_/Q sky130_fd_sc_hd__dfxtp_2
X_6669_ _6669_/A VGND VGND VPWR VPWR _6669_/Y sky130_fd_sc_hd__inv_2
XTAP_TAPCELL_ROW_21_477 VGND VPWR sky130_fd_sc_hd__tapvpwrvgnd_1
XTAP_TAPCELL_ROW_98_1365 VGND VPWR sky130_fd_sc_hd__tapvpwrvgnd_1
XFILLER_3_615 VGND VGND VPWR VPWR sky130_fd_sc_hd__fill_1
XFILLER_3_626 VGND VGND VPWR VPWR sky130_fd_sc_hd__decap_3
XFILLER_2_147 VGND VGND VPWR VPWR sky130_fd_sc_hd__decap_3
XFILLER_78_416 VGND VGND VPWR VPWR sky130_fd_sc_hd__decap_3
XFILLER_59_641 VGND VGND VPWR VPWR sky130_fd_sc_hd__decap_3
XFILLER_0_17 VGND VGND VPWR VPWR sky130_fd_sc_hd__decap_3
XFILLER_58_184 VGND VGND VPWR VPWR sky130_fd_sc_hd__decap_3
XFILLER_74_622 VGND VGND VPWR VPWR sky130_fd_sc_hd__decap_3
XFILLER_86_471 VGND VGND VPWR VPWR sky130_fd_sc_hd__fill_2
XFILLER_64_20 VGND VGND VPWR VPWR sky130_fd_sc_hd__decap_3
XFILLER_46_368 VGND VGND VPWR VPWR sky130_fd_sc_hd__decap_3
XFILLER_61_316 VGND VGND VPWR VPWR sky130_fd_sc_hd__decap_3
XTAP_TAPCELL_ROW_57_886 VGND VPWR sky130_fd_sc_hd__tapvpwrvgnd_1
XTAP_TAPCELL_ROW_29_566 VGND VPWR sky130_fd_sc_hd__tapvpwrvgnd_1
XTAP_TAPCELL_ROW_107_1461 VGND VPWR sky130_fd_sc_hd__tapvpwrvgnd_1
XFILLER_27_582 VGND VGND VPWR VPWR sky130_fd_sc_hd__decap_3
XFILLER_73_198 VGND VGND VPWR VPWR sky130_fd_sc_hd__decap_3
XFILLER_14_298 VGND VGND VPWR VPWR sky130_fd_sc_hd__decap_3
XFILLER_80_74 VGND VGND VPWR VPWR sky130_fd_sc_hd__fill_2
XFILLER_80_85 VGND VGND VPWR VPWR sky130_fd_sc_hd__decap_3
XFILLER_89_83 VGND VGND VPWR VPWR sky130_fd_sc_hd__fill_2
XFILLER_69_405 VGND VGND VPWR VPWR sky130_fd_sc_hd__fill_1
XTAP_TAPCELL_ROW_71_1048 VGND VPWR sky130_fd_sc_hd__tapvpwrvgnd_1
XFILLER_96_213 VGND VGND VPWR VPWR sky130_fd_sc_hd__fill_2
XFILLER_84_408 VGND VGND VPWR VPWR sky130_fd_sc_hd__decap_3
Xclkbuf_leaf_1_clk clkbuf_leaf_2_clk/A VGND VGND VPWR VPWR clkload3/A sky130_fd_sc_hd__clkbuf_16
X_4020_ _7086_/Q _4102_/B _4432_/B1 _4019_/X VGND VGND VPWR VPWR _4039_/A sky130_fd_sc_hd__o211ai_2
XFILLER_96_268 VGND VGND VPWR VPWR sky130_fd_sc_hd__fill_2
XFILLER_37_302 VGND VGND VPWR VPWR sky130_fd_sc_hd__decap_3
XFILLER_49_151 VGND VGND VPWR VPWR sky130_fd_sc_hd__decap_3
XFILLER_49_184 VGND VGND VPWR VPWR sky130_fd_sc_hd__decap_3
XFILLER_65_611 VGND VGND VPWR VPWR sky130_fd_sc_hd__decap_3
XFILLER_37_335 VGND VGND VPWR VPWR sky130_fd_sc_hd__fill_1
XFILLER_37_346 VGND VGND VPWR VPWR sky130_fd_sc_hd__fill_2
XFILLER_65_644 VGND VGND VPWR VPWR sky130_fd_sc_hd__decap_3
XFILLER_25_508 VGND VGND VPWR VPWR sky130_fd_sc_hd__decap_3
XFILLER_37_368 VGND VGND VPWR VPWR sky130_fd_sc_hd__fill_1
XFILLER_64_154 VGND VGND VPWR VPWR sky130_fd_sc_hd__decap_3
XFILLER_92_474 VGND VGND VPWR VPWR sky130_fd_sc_hd__fill_2
XFILLER_33_530 VGND VGND VPWR VPWR sky130_fd_sc_hd__fill_1
XFILLER_52_349 VGND VGND VPWR VPWR sky130_fd_sc_hd__decap_3
XFILLER_64_187 VGND VGND VPWR VPWR sky130_fd_sc_hd__decap_3
X_4922_ _4937_/A _4937_/B _4203_/X VGND VGND VPWR VPWR _4922_/X sky130_fd_sc_hd__a21o_2
XFILLER_100_29 VGND VGND VPWR VPWR sky130_fd_sc_hd__decap_3
XFILLER_20_224 VGND VGND VPWR VPWR sky130_fd_sc_hd__decap_3
XTAP_TAPCELL_ROW_82_1177 VGND VPWR sky130_fd_sc_hd__tapvpwrvgnd_1
X_4784_ _4813_/A _4829_/B VGND VGND VPWR VPWR _4811_/B sky130_fd_sc_hd__nand2_2
X_3804_ _6826_/Q _3881_/A2 _3913_/B1 _6811_/Q _3803_/X VGND VGND VPWR VPWR _3804_/X
+ sky130_fd_sc_hd__a221o_2
X_6523_ _6524_/A VGND VGND VPWR VPWR _6523_/Y sky130_fd_sc_hd__inv_2
X_3735_ _3735_/A _3746_/B _3746_/C VGND VGND VPWR VPWR _3735_/X sky130_fd_sc_hd__and3_4
X_6454_ _6614_/A VGND VGND VPWR VPWR _6454_/Y sky130_fd_sc_hd__inv_2
XFILLER_106_318 VGND VGND VPWR VPWR sky130_fd_sc_hd__decap_3
X_6385_ _6618_/A VGND VGND VPWR VPWR _6385_/Y sky130_fd_sc_hd__inv_2
X_3597_ _4295_/B _3607_/B VGND VGND VPWR VPWR _3611_/B sky130_fd_sc_hd__nor2_2
XFILLER_0_629 VGND VGND VPWR VPWR sky130_fd_sc_hd__decap_3
XFILLER_87_202 VGND VGND VPWR VPWR sky130_fd_sc_hd__fill_2
X_5336_ _5336_/A0 _5040_/X _5358_/S VGND VGND VPWR VPWR _7163_/D sky130_fd_sc_hd__mux2_2
XFILLER_87_279 VGND VGND VPWR VPWR sky130_fd_sc_hd__fill_1
X_7006_ _7373_/CLK _7006_/D _6286_/Y VGND VGND VPWR VPWR _7006_/Q sky130_fd_sc_hd__dfrtp_2
X_4218_ _7100_/Q _4351_/A2 _4351_/B1 _7132_/Q VGND VGND VPWR VPWR _4218_/X sky130_fd_sc_hd__a22o_2
XFILLER_18_24 VGND VGND VPWR VPWR sky130_fd_sc_hd__decap_3
XFILLER_28_302 VGND VGND VPWR VPWR sky130_fd_sc_hd__decap_3
XFILLER_56_633 VGND VGND VPWR VPWR sky130_fd_sc_hd__decap_3
X_5198_ _5198_/A _5207_/B VGND VGND VPWR VPWR _7229_/D sky130_fd_sc_hd__and2_2
XFILLER_18_57 VGND VGND VPWR VPWR sky130_fd_sc_hd__fill_2
XFILLER_18_68 VGND VGND VPWR VPWR sky130_fd_sc_hd__decap_3
XFILLER_55_110 VGND VGND VPWR VPWR sky130_fd_sc_hd__fill_2
XFILLER_55_121 VGND VGND VPWR VPWR sky130_fd_sc_hd__fill_2
XFILLER_55_143 VGND VGND VPWR VPWR sky130_fd_sc_hd__decap_3
XFILLER_95_290 VGND VGND VPWR VPWR sky130_fd_sc_hd__decap_3
X_4149_ _4205_/A _4205_/B VGND VGND VPWR VPWR _4157_/A sky130_fd_sc_hd__nand2_2
XFILLER_55_165 VGND VGND VPWR VPWR sky130_fd_sc_hd__decap_3
XFILLER_83_485 VGND VGND VPWR VPWR sky130_fd_sc_hd__fill_1
XFILLER_55_187 VGND VGND VPWR VPWR sky130_fd_sc_hd__decap_3
XFILLER_70_124 VGND VGND VPWR VPWR sky130_fd_sc_hd__decap_3
XFILLER_71_647 VGND VGND VPWR VPWR sky130_fd_sc_hd__fill_1
XTAP_TAPCELL_ROW_26_536 VGND VPWR sky130_fd_sc_hd__tapvpwrvgnd_1
XFILLER_24_552 VGND VGND VPWR VPWR sky130_fd_sc_hd__decap_3
XTAP_TAPCELL_ROW_54_856 VGND VPWR sky130_fd_sc_hd__tapvpwrvgnd_1
XFILLER_24_574 VGND VGND VPWR VPWR sky130_fd_sc_hd__decap_3
XFILLER_11_257 VGND VGND VPWR VPWR sky130_fd_sc_hd__decap_3
XFILLER_51_393 VGND VGND VPWR VPWR sky130_fd_sc_hd__fill_2
XFILLER_50_33 VGND VGND VPWR VPWR sky130_fd_sc_hd__fill_1
XFILLER_7_228 VGND VGND VPWR VPWR sky130_fd_sc_hd__decap_3
Xclkload0 clkload0/A VGND VGND VPWR VPWR clkload0/X sky130_fd_sc_hd__clkbuf_16
XFILLER_3_423 VGND VGND VPWR VPWR sky130_fd_sc_hd__decap_3
XFILLER_3_434 VGND VGND VPWR VPWR sky130_fd_sc_hd__decap_3
XFILLER_105_340 VGND VGND VPWR VPWR sky130_fd_sc_hd__decap_3
XFILLER_105_362 VGND VGND VPWR VPWR sky130_fd_sc_hd__decap_3
XFILLER_59_31 VGND VGND VPWR VPWR sky130_fd_sc_hd__fill_1
XFILLER_46_121 VGND VGND VPWR VPWR sky130_fd_sc_hd__decap_3
XFILLER_47_644 VGND VGND VPWR VPWR sky130_fd_sc_hd__decap_3
XFILLER_34_305 VGND VGND VPWR VPWR sky130_fd_sc_hd__decap_3
XFILLER_46_165 VGND VGND VPWR VPWR sky130_fd_sc_hd__fill_1
XFILLER_75_85 VGND VGND VPWR VPWR sky130_fd_sc_hd__decap_3
XFILLER_61_124 VGND VGND VPWR VPWR sky130_fd_sc_hd__fill_2
XFILLER_62_636 VGND VGND VPWR VPWR sky130_fd_sc_hd__decap_3
XFILLER_15_585 VGND VGND VPWR VPWR sky130_fd_sc_hd__decap_3
XFILLER_42_371 VGND VGND VPWR VPWR sky130_fd_sc_hd__decap_3
XFILLER_30_533 VGND VGND VPWR VPWR sky130_fd_sc_hd__decap_3
XFILLER_30_544 VGND VGND VPWR VPWR sky130_fd_sc_hd__decap_3
XFILLER_42_393 VGND VGND VPWR VPWR sky130_fd_sc_hd__fill_2
X_3520_ _5118_/D _3354_/X _3519_/Y _3350_/B VGND VGND VPWR VPWR _3525_/B sky130_fd_sc_hd__o2bb2a_2
Xhold707 _6977_/Q VGND VGND VPWR VPWR _6977_/D sky130_fd_sc_hd__dlygate4sd3_1
Xhold718 _6902_/Q VGND VGND VPWR VPWR _6902_/D sky130_fd_sc_hd__dlygate4sd3_1
Xhold729 _6763_/Q VGND VGND VPWR VPWR _6763_/D sky130_fd_sc_hd__dlygate4sd3_1
XFILLER_69_202 VGND VGND VPWR VPWR sky130_fd_sc_hd__decap_3
X_5121_ _5092_/C _5117_/X _5118_/X _6984_/D _5642_/A VGND VGND VPWR VPWR _5121_/X
+ sky130_fd_sc_hd__a32o_2
XFILLER_57_408 VGND VGND VPWR VPWR sky130_fd_sc_hd__decap_3
XFILLER_97_555 VGND VGND VPWR VPWR sky130_fd_sc_hd__decap_3
XFILLER_38_600 VGND VGND VPWR VPWR sky130_fd_sc_hd__decap_3
X_5052_ _3548_/X _5049_/X _5051_/X _3618_/X VGND VGND VPWR VPWR _5052_/X sky130_fd_sc_hd__a2bb2o_2
XFILLER_38_633 VGND VGND VPWR VPWR sky130_fd_sc_hd__decap_3
XFILLER_1_60 VGND VGND VPWR VPWR sky130_fd_sc_hd__decap_3
XFILLER_37_154 VGND VGND VPWR VPWR sky130_fd_sc_hd__decap_3
XFILLER_53_614 VGND VGND VPWR VPWR sky130_fd_sc_hd__fill_2
XTAP_TAPCELL_ROW_84_1206 VGND VPWR sky130_fd_sc_hd__tapvpwrvgnd_1
XFILLER_52_124 VGND VGND VPWR VPWR sky130_fd_sc_hd__decap_3
XFILLER_53_647 VGND VGND VPWR VPWR sky130_fd_sc_hd__fill_1
XFILLER_65_496 VGND VGND VPWR VPWR sky130_fd_sc_hd__decap_3
XFILLER_52_146 VGND VGND VPWR VPWR sky130_fd_sc_hd__decap_3
XFILLER_52_168 VGND VGND VPWR VPWR sky130_fd_sc_hd__decap_3
XFILLER_21_511 VGND VGND VPWR VPWR sky130_fd_sc_hd__fill_1
XFILLER_33_360 VGND VGND VPWR VPWR sky130_fd_sc_hd__fill_1
X_4905_ _5006_/A1 _4888_/A _4903_/A _5101_/A VGND VGND VPWR VPWR _4905_/X sky130_fd_sc_hd__o2bb2a_2
XTAP_TAPCELL_ROW_51_826 VGND VPWR sky130_fd_sc_hd__tapvpwrvgnd_1
X_4836_ _7001_/D _4835_/X _5061_/S VGND VGND VPWR VPWR _4836_/X sky130_fd_sc_hd__mux2_2
XFILLER_21_599 VGND VGND VPWR VPWR sky130_fd_sc_hd__decap_3
X_6506_ _6638_/A VGND VGND VPWR VPWR _6506_/Y sky130_fd_sc_hd__inv_2
X_4767_ _5057_/A _4452_/A _4453_/A _4852_/A _4766_/Y VGND VGND VPWR VPWR _4767_/X
+ sky130_fd_sc_hd__o221a_2
XTAP_TAPCELL_ROW_31_594 VGND VPWR sky130_fd_sc_hd__tapvpwrvgnd_1
XFILLER_4_209 VGND VGND VPWR VPWR sky130_fd_sc_hd__decap_3
X_4698_ _6985_/Q _5120_/A VGND VGND VPWR VPWR _5098_/A sky130_fd_sc_hd__and2_2
XTAP_TAPCELL_ROW_95_1324 VGND VPWR sky130_fd_sc_hd__tapvpwrvgnd_1
X_6437_ _6628_/A VGND VGND VPWR VPWR _6437_/Y sky130_fd_sc_hd__inv_2
X_6368_ _6566_/A VGND VGND VPWR VPWR _6368_/Y sky130_fd_sc_hd__inv_2
XFILLER_0_426 VGND VGND VPWR VPWR sky130_fd_sc_hd__decap_3
XFILLER_0_437 VGND VGND VPWR VPWR sky130_fd_sc_hd__decap_3
XFILLER_102_321 VGND VGND VPWR VPWR sky130_fd_sc_hd__decap_3
XFILLER_88_533 VGND VGND VPWR VPWR sky130_fd_sc_hd__decap_3
X_5319_ _5319_/A0 _4913_/X _5333_/S VGND VGND VPWR VPWR _7171_/D sky130_fd_sc_hd__mux2_2
X_6299_ _6650_/A VGND VGND VPWR VPWR _6299_/Y sky130_fd_sc_hd__inv_2
XFILLER_102_376 VGND VGND VPWR VPWR sky130_fd_sc_hd__decap_3
XFILLER_29_611 VGND VGND VPWR VPWR sky130_fd_sc_hd__decap_3
XFILLER_75_205 VGND VGND VPWR VPWR sky130_fd_sc_hd__decap_3
XTAP_TAPCELL_ROW_59_915 VGND VPWR sky130_fd_sc_hd__tapvpwrvgnd_1
XFILLER_102_398 VGND VGND VPWR VPWR sky130_fd_sc_hd__fill_2
XFILLER_29_644 VGND VGND VPWR VPWR sky130_fd_sc_hd__decap_3
XFILLER_29_89 VGND VGND VPWR VPWR sky130_fd_sc_hd__decap_3
XFILLER_68_290 VGND VGND VPWR VPWR sky130_fd_sc_hd__decap_3
XFILLER_75_238 VGND VGND VPWR VPWR sky130_fd_sc_hd__decap_3
XFILLER_56_474 VGND VGND VPWR VPWR sky130_fd_sc_hd__fill_2
XTAP_TAPCELL_ROW_3_264 VGND VPWR sky130_fd_sc_hd__tapvpwrvgnd_1
XFILLER_16_338 VGND VGND VPWR VPWR sky130_fd_sc_hd__decap_3
XFILLER_43_113 VGND VGND VPWR VPWR sky130_fd_sc_hd__decap_3
XFILLER_44_625 VGND VGND VPWR VPWR sky130_fd_sc_hd__decap_3
XFILLER_71_422 VGND VGND VPWR VPWR sky130_fd_sc_hd__decap_3
XFILLER_83_271 VGND VGND VPWR VPWR sky130_fd_sc_hd__decap_3
XFILLER_83_293 VGND VGND VPWR VPWR sky130_fd_sc_hd__decap_3
XTAP_TAPCELL_ROW_39_683 VGND VPWR sky130_fd_sc_hd__tapvpwrvgnd_1
XFILLER_45_66 VGND VGND VPWR VPWR sky130_fd_sc_hd__decap_3
XFILLER_45_88 VGND VGND VPWR VPWR sky130_fd_sc_hd__fill_2
XTAP_TAPCELL_ROW_104_1431 VGND VPWR sky130_fd_sc_hd__tapvpwrvgnd_1
XFILLER_24_360 VGND VGND VPWR VPWR sky130_fd_sc_hd__fill_1
XFILLER_71_488 VGND VGND VPWR VPWR sky130_fd_sc_hd__decap_3
XFILLER_12_555 VGND VGND VPWR VPWR sky130_fd_sc_hd__decap_3
XANTENNA_9 _3749_/Y VGND VGND VPWR VPWR sky130_fd_sc_hd__diode_2
XFILLER_6_27 VGND VGND VPWR VPWR sky130_fd_sc_hd__fill_1
XFILLER_3_231 VGND VGND VPWR VPWR sky130_fd_sc_hd__decap_3
XFILLER_79_500 VGND VGND VPWR VPWR sky130_fd_sc_hd__decap_3
XFILLER_79_511 VGND VGND VPWR VPWR sky130_fd_sc_hd__decap_3
XFILLER_39_408 VGND VGND VPWR VPWR sky130_fd_sc_hd__fill_1
XFILLER_3_297 VGND VGND VPWR VPWR sky130_fd_sc_hd__decap_3
XFILLER_79_544 VGND VGND VPWR VPWR sky130_fd_sc_hd__decap_3
XFILLER_66_238 VGND VGND VPWR VPWR sky130_fd_sc_hd__decap_3
XFILLER_94_569 VGND VGND VPWR VPWR sky130_fd_sc_hd__decap_3
XFILLER_19_143 VGND VGND VPWR VPWR sky130_fd_sc_hd__decap_3
XFILLER_47_474 VGND VGND VPWR VPWR sky130_fd_sc_hd__decap_3
XFILLER_81_208 VGND VGND VPWR VPWR sky130_fd_sc_hd__fill_2
XFILLER_35_647 VGND VGND VPWR VPWR sky130_fd_sc_hd__fill_1
XFILLER_62_466 VGND VGND VPWR VPWR sky130_fd_sc_hd__fill_2
XFILLER_34_168 VGND VGND VPWR VPWR sky130_fd_sc_hd__fill_1
XFILLER_50_617 VGND VGND VPWR VPWR sky130_fd_sc_hd__decap_3
XFILLER_62_477 VGND VGND VPWR VPWR sky130_fd_sc_hd__decap_3
XFILLER_15_393 VGND VGND VPWR VPWR sky130_fd_sc_hd__decap_3
X_5670_ _5670_/A _5670_/B VGND VGND VPWR VPWR _5671_/B sky130_fd_sc_hd__nand2_2
XFILLER_30_363 VGND VGND VPWR VPWR sky130_fd_sc_hd__fill_1
X_4621_ _4315_/B _4343_/X _4315_/A VGND VGND VPWR VPWR _4621_/X sky130_fd_sc_hd__a21bo_2
X_7340_ _7373_/CLK _7340_/D _6620_/Y VGND VGND VPWR VPWR _7340_/Q sky130_fd_sc_hd__dfrtp_2
X_4552_ _4552_/A _4563_/B VGND VGND VPWR VPWR _7304_/D sky130_fd_sc_hd__and2_2
XFILLER_7_570 VGND VGND VPWR VPWR sky130_fd_sc_hd__decap_3
X_7271_ _7405_/CLK _7271_/D _6551_/Y VGND VGND VPWR VPWR _7271_/Q sky130_fd_sc_hd__dfrtp_2
X_3503_ _3545_/A _3545_/B VGND VGND VPWR VPWR _3630_/A sky130_fd_sc_hd__xor2_4
X_3434_ _7218_/Q _3377_/X _4348_/B1 _7122_/Q VGND VGND VPWR VPWR _3434_/X sky130_fd_sc_hd__a22o_2
XFILLER_106_17 VGND VGND VPWR VPWR sky130_fd_sc_hd__decap_3
X_3365_ _3365_/A VGND VGND VPWR VPWR _5118_/A sky130_fd_sc_hd__inv_2
XTAP_TAPCELL_ROW_90_1265 VGND VPWR sky130_fd_sc_hd__tapvpwrvgnd_1
XFILLER_97_352 VGND VGND VPWR VPWR sky130_fd_sc_hd__decap_3
XFILLER_57_205 VGND VGND VPWR VPWR sky130_fd_sc_hd__decap_3
XFILLER_85_514 VGND VGND VPWR VPWR sky130_fd_sc_hd__decap_3
Xhold1204 _7306_/Q VGND VGND VPWR VPWR _4548_/A sky130_fd_sc_hd__dlygate4sd3_1
Xhold1215 _7326_/Q VGND VGND VPWR VPWR _4507_/A0 sky130_fd_sc_hd__dlygate4sd3_1
X_5104_ _5104_/A _5660_/C VGND VGND VPWR VPWR _5104_/Y sky130_fd_sc_hd__nand2_2
XFILLER_57_249 VGND VGND VPWR VPWR sky130_fd_sc_hd__fill_1
XFILLER_85_547 VGND VGND VPWR VPWR sky130_fd_sc_hd__decap_3
XFILLER_85_569 VGND VGND VPWR VPWR sky130_fd_sc_hd__decap_3
XFILLER_97_396 VGND VGND VPWR VPWR sky130_fd_sc_hd__decap_3
XFILLER_26_614 VGND VGND VPWR VPWR sky130_fd_sc_hd__decap_3
XFILLER_25_102 VGND VGND VPWR VPWR sky130_fd_sc_hd__decap_3
XFILLER_53_422 VGND VGND VPWR VPWR sky130_fd_sc_hd__decap_3
XFILLER_65_293 VGND VGND VPWR VPWR sky130_fd_sc_hd__decap_3
XTAP_TAPCELL_ROW_0_234 VGND VPWR sky130_fd_sc_hd__tapvpwrvgnd_1
XTAP_TAPCELL_ROW_0_223 VGND VPWR sky130_fd_sc_hd__tapvpwrvgnd_1
XFILLER_53_466 VGND VGND VPWR VPWR sky130_fd_sc_hd__decap_3
X_6986_ _7398_/CLK _6986_/D _6266_/Y VGND VGND VPWR VPWR _6986_/Q sky130_fd_sc_hd__dfrtp_2
XTAP_TAPCELL_ROW_36_653 VGND VPWR sky130_fd_sc_hd__tapvpwrvgnd_1
XFILLER_13_319 VGND VGND VPWR VPWR sky130_fd_sc_hd__decap_3
XFILLER_40_116 VGND VGND VPWR VPWR sky130_fd_sc_hd__decap_3
XFILLER_41_617 VGND VGND VPWR VPWR sky130_fd_sc_hd__decap_3
XFILLER_53_488 VGND VGND VPWR VPWR sky130_fd_sc_hd__decap_3
XFILLER_80_263 VGND VGND VPWR VPWR sky130_fd_sc_hd__decap_3
XTAP_TAPCELL_ROW_64_973 VGND VPWR sky130_fd_sc_hd__tapvpwrvgnd_1
XFILLER_40_138 VGND VGND VPWR VPWR sky130_fd_sc_hd__fill_2
X_4819_ _7002_/Q _4834_/A _4818_/Y _4777_/A VGND VGND VPWR VPWR _4819_/X sky130_fd_sc_hd__o211a_2
XFILLER_107_402 VGND VGND VPWR VPWR sky130_fd_sc_hd__decap_3
XFILLER_107_413 VGND VGND VPWR VPWR sky130_fd_sc_hd__decap_3
XFILLER_31_57 VGND VGND VPWR VPWR sky130_fd_sc_hd__decap_3
XTAP_TAPCELL_ROW_8_323 VGND VPWR sky130_fd_sc_hd__tapvpwrvgnd_1
XFILLER_0_234 VGND VGND VPWR VPWR sky130_fd_sc_hd__decap_3
XFILLER_0_245 VGND VGND VPWR VPWR sky130_fd_sc_hd__decap_3
XFILLER_103_641 VGND VGND VPWR VPWR sky130_fd_sc_hd__decap_3
XFILLER_88_330 VGND VGND VPWR VPWR sky130_fd_sc_hd__decap_3
XFILLER_0_256 VGND VGND VPWR VPWR sky130_fd_sc_hd__decap_3
XFILLER_0_278 VGND VGND VPWR VPWR sky130_fd_sc_hd__fill_2
XFILLER_102_162 VGND VGND VPWR VPWR sky130_fd_sc_hd__decap_3
XFILLER_76_525 VGND VGND VPWR VPWR sky130_fd_sc_hd__decap_3
XFILLER_88_363 VGND VGND VPWR VPWR sky130_fd_sc_hd__fill_1
XFILLER_48_227 VGND VGND VPWR VPWR sky130_fd_sc_hd__fill_1
XFILLER_76_536 VGND VGND VPWR VPWR sky130_fd_sc_hd__decap_3
XFILLER_17_603 VGND VGND VPWR VPWR sky130_fd_sc_hd__decap_3
XFILLER_56_43 VGND VGND VPWR VPWR sky130_fd_sc_hd__fill_2
XFILLER_91_517 VGND VGND VPWR VPWR sky130_fd_sc_hd__decap_3
XFILLER_17_647 VGND VGND VPWR VPWR sky130_fd_sc_hd__fill_1
XFILLER_44_411 VGND VGND VPWR VPWR sky130_fd_sc_hd__fill_2
XFILLER_16_124 VGND VGND VPWR VPWR sky130_fd_sc_hd__decap_3
XPHY_EDGE_ROW_19_Right_19 VGND VGND VPWR VPWR sky130_fd_sc_hd__decap_3
XFILLER_16_168 VGND VGND VPWR VPWR sky130_fd_sc_hd__decap_3
XFILLER_16_179 VGND VGND VPWR VPWR sky130_fd_sc_hd__decap_3
XFILLER_32_628 VGND VGND VPWR VPWR sky130_fd_sc_hd__decap_3
XFILLER_8_312 VGND VGND VPWR VPWR sky130_fd_sc_hd__decap_3
XFILLER_12_396 VGND VGND VPWR VPWR sky130_fd_sc_hd__decap_3
Xclkbuf_3_1__f_clk clkbuf_0_clk/X VGND VGND VPWR VPWR clkbuf_leaf_7_clk/A sky130_fd_sc_hd__clkbuf_16
XFILLER_4_551 VGND VGND VPWR VPWR sky130_fd_sc_hd__decap_3
XPHY_EDGE_ROW_28_Right_28 VGND VGND VPWR VPWR sky130_fd_sc_hd__decap_3
XFILLER_4_584 VGND VGND VPWR VPWR sky130_fd_sc_hd__decap_3
XFILLER_4_595 VGND VGND VPWR VPWR sky130_fd_sc_hd__decap_3
XFILLER_79_352 VGND VGND VPWR VPWR sky130_fd_sc_hd__decap_3
XFILLER_39_205 VGND VGND VPWR VPWR sky130_fd_sc_hd__decap_3
XFILLER_79_374 VGND VGND VPWR VPWR sky130_fd_sc_hd__decap_3
XFILLER_97_94 VGND VGND VPWR VPWR sky130_fd_sc_hd__decap_3
XFILLER_54_208 VGND VGND VPWR VPWR sky130_fd_sc_hd__decap_3
XFILLER_82_539 VGND VGND VPWR VPWR sky130_fd_sc_hd__fill_1
XFILLER_94_399 VGND VGND VPWR VPWR sky130_fd_sc_hd__decap_3
XPHY_EDGE_ROW_37_Right_37 VGND VGND VPWR VPWR sky130_fd_sc_hd__decap_3
XFILLER_35_455 VGND VGND VPWR VPWR sky130_fd_sc_hd__decap_3
XFILLER_62_230 VGND VGND VPWR VPWR sky130_fd_sc_hd__decap_3
XFILLER_90_550 VGND VGND VPWR VPWR sky130_fd_sc_hd__decap_3
X_6840_ clkload6/A _6840_/D VGND VGND VPWR VPWR _6840_/Q sky130_fd_sc_hd__dfxtp_2
XFILLER_23_617 VGND VGND VPWR VPWR sky130_fd_sc_hd__decap_3
XFILLER_90_561 VGND VGND VPWR VPWR sky130_fd_sc_hd__decap_3
XFILLER_90_583 VGND VGND VPWR VPWR sky130_fd_sc_hd__fill_2
X_6771_ _6963_/CLK _6771_/D VGND VGND VPWR VPWR _6771_/Q sky130_fd_sc_hd__dfxtp_2
XTAP_TAPCELL_ROW_33_612 VGND VPWR sky130_fd_sc_hd__tapvpwrvgnd_1
XFILLER_22_149 VGND VGND VPWR VPWR sky130_fd_sc_hd__decap_3
X_3983_ _7349_/Q _4524_/A0 _3994_/S VGND VGND VPWR VPWR _7349_/D sky130_fd_sc_hd__mux2_2
XTAP_TAPCELL_ROW_61_932 VGND VPWR sky130_fd_sc_hd__tapvpwrvgnd_1
X_5653_ _5664_/B VGND VGND VPWR VPWR _5653_/Y sky130_fd_sc_hd__inv_2
X_4604_ _4667_/B VGND VGND VPWR VPWR _5628_/B sky130_fd_sc_hd__inv_2
XTAP_TAPCELL_ROW_79_1138 VGND VPWR sky130_fd_sc_hd__tapvpwrvgnd_1
XTAP_TAPCELL_ROW_13_380 VGND VPWR sky130_fd_sc_hd__tapvpwrvgnd_1
XPHY_EDGE_ROW_46_Right_46 VGND VGND VPWR VPWR sky130_fd_sc_hd__decap_3
X_7323_ _7356_/CLK _7323_/D _6603_/Y VGND VGND VPWR VPWR _7323_/Q sky130_fd_sc_hd__dfrtp_2
XFILLER_104_405 VGND VGND VPWR VPWR sky130_fd_sc_hd__decap_3
XFILLER_104_427 VGND VGND VPWR VPWR sky130_fd_sc_hd__decap_3
XFILLER_89_116 VGND VGND VPWR VPWR sky130_fd_sc_hd__decap_3
X_7254_ _7350_/CLK _7254_/D _6534_/Y VGND VGND VPWR VPWR _7254_/Q sky130_fd_sc_hd__dfrtp_2
X_4466_ _5104_/A _5650_/A VGND VGND VPWR VPWR _4466_/Y sky130_fd_sc_hd__nand2_2
X_7185_ _7376_/CLK _7185_/D _6465_/Y VGND VGND VPWR VPWR _7185_/Q sky130_fd_sc_hd__dfrtp_2
X_4397_ _4397_/A _4648_/A VGND VGND VPWR VPWR _4447_/A sky130_fd_sc_hd__nor2_2
X_3417_ _3449_/B _3421_/C _3417_/C VGND VGND VPWR VPWR _3417_/X sky130_fd_sc_hd__and3_2
X_3348_ _6981_/Q _3327_/B _5129_/A VGND VGND VPWR VPWR _5130_/A sky130_fd_sc_hd__a21oi_2
Xhold1001 _7191_/Q VGND VGND VPWR VPWR _5278_/A0 sky130_fd_sc_hd__dlygate4sd3_1
Xhold1012 _7205_/Q VGND VGND VPWR VPWR _5249_/A0 sky130_fd_sc_hd__dlygate4sd3_1
Xhold1023 _7254_/Q VGND VGND VPWR VPWR _5122_/A0 sky130_fd_sc_hd__dlygate4sd3_1
XFILLER_85_355 VGND VGND VPWR VPWR sky130_fd_sc_hd__decap_3
Xhold1034 _7207_/Q VGND VGND VPWR VPWR _5245_/A0 sky130_fd_sc_hd__dlygate4sd3_1
Xhold1045 _7271_/Q VGND VGND VPWR VPWR _4837_/A0 sky130_fd_sc_hd__dlygate4sd3_1
Xhold1056 _7218_/Q VGND VGND VPWR VPWR _5221_/A sky130_fd_sc_hd__dlygate4sd3_1
Xhold1067 _7238_/Q VGND VGND VPWR VPWR _5179_/A sky130_fd_sc_hd__dlygate4sd3_1
XPHY_EDGE_ROW_55_Right_55 VGND VGND VPWR VPWR sky130_fd_sc_hd__decap_3
XFILLER_38_271 VGND VGND VPWR VPWR sky130_fd_sc_hd__decap_3
XFILLER_73_539 VGND VGND VPWR VPWR sky130_fd_sc_hd__decap_3
XFILLER_85_388 VGND VGND VPWR VPWR sky130_fd_sc_hd__decap_3
XFILLER_85_399 VGND VGND VPWR VPWR sky130_fd_sc_hd__fill_2
Xhold1078 _7406_/Q VGND VGND VPWR VPWR _3645_/A1 sky130_fd_sc_hd__dlygate4sd3_1
Xhold1089 _7240_/Q VGND VGND VPWR VPWR _5175_/A sky130_fd_sc_hd__dlygate4sd3_1
X_5018_ _5018_/A _5018_/B VGND VGND VPWR VPWR _5018_/Y sky130_fd_sc_hd__nor2_2
XFILLER_26_433 VGND VGND VPWR VPWR sky130_fd_sc_hd__decap_3
XFILLER_26_46 VGND VGND VPWR VPWR sky130_fd_sc_hd__decap_3
XFILLER_14_628 VGND VGND VPWR VPWR sky130_fd_sc_hd__decap_3
XFILLER_26_477 VGND VGND VPWR VPWR sky130_fd_sc_hd__decap_3
XFILLER_53_252 VGND VGND VPWR VPWR sky130_fd_sc_hd__decap_3
XFILLER_81_561 VGND VGND VPWR VPWR sky130_fd_sc_hd__fill_1
XFILLER_13_116 VGND VGND VPWR VPWR sky130_fd_sc_hd__decap_3
X_6969_ _6974_/CLK _6969_/D VGND VGND VPWR VPWR _6969_/Q sky130_fd_sc_hd__dfxtp_2
XTAP_TAPCELL_ROW_101_1401 VGND VPWR sky130_fd_sc_hd__tapvpwrvgnd_1
XFILLER_21_160 VGND VGND VPWR VPWR sky130_fd_sc_hd__decap_3
XPHY_EDGE_ROW_64_Right_64 VGND VGND VPWR VPWR sky130_fd_sc_hd__decap_3
XFILLER_5_315 VGND VGND VPWR VPWR sky130_fd_sc_hd__fill_1
XFILLER_5_337 VGND VGND VPWR VPWR sky130_fd_sc_hd__decap_3
XPHY_EDGE_ROW_2_Left_111 VGND VGND VPWR VPWR sky130_fd_sc_hd__decap_3
XFILLER_107_254 VGND VGND VPWR VPWR sky130_fd_sc_hd__decap_3
XPHY_EDGE_ROW_39_Left_148 VGND VGND VPWR VPWR sky130_fd_sc_hd__decap_3
XFILLER_1_532 VGND VGND VPWR VPWR sky130_fd_sc_hd__decap_3
Xhold890 _7086_/Q VGND VGND VPWR VPWR _7086_/D sky130_fd_sc_hd__dlygate4sd3_1
XFILLER_107_60 VGND VGND VPWR VPWR sky130_fd_sc_hd__decap_3
XFILLER_1_576 VGND VGND VPWR VPWR sky130_fd_sc_hd__decap_3
XFILLER_88_160 VGND VGND VPWR VPWR sky130_fd_sc_hd__decap_3
XFILLER_103_493 VGND VGND VPWR VPWR sky130_fd_sc_hd__decap_3
XPHY_EDGE_ROW_73_Right_73 VGND VGND VPWR VPWR sky130_fd_sc_hd__decap_3
XFILLER_64_506 VGND VGND VPWR VPWR sky130_fd_sc_hd__decap_3
XFILLER_67_86 VGND VGND VPWR VPWR sky130_fd_sc_hd__fill_2
XFILLER_76_355 VGND VGND VPWR VPWR sky130_fd_sc_hd__decap_3
XFILLER_76_377 VGND VGND VPWR VPWR sky130_fd_sc_hd__decap_3
XFILLER_57_580 VGND VGND VPWR VPWR sky130_fd_sc_hd__decap_3
XPHY_EDGE_ROW_48_Left_157 VGND VGND VPWR VPWR sky130_fd_sc_hd__decap_3
XFILLER_17_433 VGND VGND VPWR VPWR sky130_fd_sc_hd__decap_3
XFILLER_44_241 VGND VGND VPWR VPWR sky130_fd_sc_hd__decap_3
XFILLER_72_561 VGND VGND VPWR VPWR sky130_fd_sc_hd__decap_3
XFILLER_83_74 VGND VGND VPWR VPWR sky130_fd_sc_hd__decap_3
XFILLER_32_436 VGND VGND VPWR VPWR sky130_fd_sc_hd__fill_1
XFILLER_44_285 VGND VGND VPWR VPWR sky130_fd_sc_hd__decap_3
XFILLER_72_594 VGND VGND VPWR VPWR sky130_fd_sc_hd__decap_3
XFILLER_32_458 VGND VGND VPWR VPWR sky130_fd_sc_hd__decap_3
XPHY_EDGE_ROW_82_Right_82 VGND VGND VPWR VPWR sky130_fd_sc_hd__decap_3
XFILLER_12_171 VGND VGND VPWR VPWR sky130_fd_sc_hd__decap_3
XFILLER_9_632 VGND VGND VPWR VPWR sky130_fd_sc_hd__decap_3
XFILLER_40_491 VGND VGND VPWR VPWR sky130_fd_sc_hd__decap_3
XFILLER_8_153 VGND VGND VPWR VPWR sky130_fd_sc_hd__decap_3
XFILLER_8_175 VGND VGND VPWR VPWR sky130_fd_sc_hd__decap_3
XTAP_TAPCELL_ROW_10_350 VGND VPWR sky130_fd_sc_hd__tapvpwrvgnd_1
XPHY_EDGE_ROW_57_Left_166 VGND VGND VPWR VPWR sky130_fd_sc_hd__decap_3
X_4320_ _7066_/Q _4265_/B _4205_/A VGND VGND VPWR VPWR _4362_/B sky130_fd_sc_hd__o21a_2
XFILLER_99_436 VGND VGND VPWR VPWR sky130_fd_sc_hd__decap_3
XFILLER_99_425 VGND VGND VPWR VPWR sky130_fd_sc_hd__fill_2
XFILLER_4_392 VGND VGND VPWR VPWR sky130_fd_sc_hd__decap_3
X_4251_ _7016_/Q _4601_/S _4351_/B1 _7133_/Q _4250_/X VGND VGND VPWR VPWR _4251_/X
+ sky130_fd_sc_hd__a221o_2
XFILLER_99_469 VGND VGND VPWR VPWR sky130_fd_sc_hd__decap_3
XFILLER_101_419 VGND VGND VPWR VPWR sky130_fd_sc_hd__decap_3
XFILLER_86_119 VGND VGND VPWR VPWR sky130_fd_sc_hd__decap_3
XPHY_EDGE_ROW_91_Right_91 VGND VGND VPWR VPWR sky130_fd_sc_hd__decap_3
XFILLER_79_193 VGND VGND VPWR VPWR sky130_fd_sc_hd__fill_1
X_4182_ _7136_/Q _4267_/A2 _4180_/X _4181_/X VGND VGND VPWR VPWR _4182_/X sky130_fd_sc_hd__a211o_2
XFILLER_95_642 VGND VGND VPWR VPWR sky130_fd_sc_hd__decap_3
XFILLER_55_517 VGND VGND VPWR VPWR sky130_fd_sc_hd__decap_3
XFILLER_94_141 VGND VGND VPWR VPWR sky130_fd_sc_hd__fill_2
XPHY_EDGE_ROW_66_Left_175 VGND VGND VPWR VPWR sky130_fd_sc_hd__decap_3
XFILLER_103_18 VGND VGND VPWR VPWR sky130_fd_sc_hd__decap_3
XFILLER_67_388 VGND VGND VPWR VPWR sky130_fd_sc_hd__decap_3
XFILLER_67_399 VGND VGND VPWR VPWR sky130_fd_sc_hd__decap_3
XFILLER_82_347 VGND VGND VPWR VPWR sky130_fd_sc_hd__decap_3
XFILLER_23_414 VGND VGND VPWR VPWR sky130_fd_sc_hd__fill_1
XFILLER_50_200 VGND VGND VPWR VPWR sky130_fd_sc_hd__fill_1
XFILLER_63_550 VGND VGND VPWR VPWR sky130_fd_sc_hd__decap_3
XFILLER_63_561 VGND VGND VPWR VPWR sky130_fd_sc_hd__decap_3
XFILLER_50_211 VGND VGND VPWR VPWR sky130_fd_sc_hd__fill_1
XFILLER_50_222 VGND VGND VPWR VPWR sky130_fd_sc_hd__decap_3
XFILLER_50_233 VGND VGND VPWR VPWR sky130_fd_sc_hd__decap_3
XFILLER_90_391 VGND VGND VPWR VPWR sky130_fd_sc_hd__fill_1
X_6823_ _6974_/CLK _6823_/D VGND VGND VPWR VPWR _6823_/Q sky130_fd_sc_hd__dfxtp_2
XFILLER_11_609 VGND VGND VPWR VPWR sky130_fd_sc_hd__decap_3
XFILLER_23_458 VGND VGND VPWR VPWR sky130_fd_sc_hd__fill_2
X_6754_ _6976_/CLK _6754_/D VGND VGND VPWR VPWR _6754_/Q sky130_fd_sc_hd__dfxtp_2
X_3966_ _7357_/Q hold979/X _3966_/S VGND VGND VPWR VPWR _7357_/D sky130_fd_sc_hd__mux2_2
X_6685_ _6685_/A VGND VGND VPWR VPWR _6685_/Y sky130_fd_sc_hd__inv_2
X_5705_ hold903/X _5721_/S _4270_/Y VGND VGND VPWR VPWR _6702_/D sky130_fd_sc_hd__a21bo_2
XFILLER_12_26 VGND VGND VPWR VPWR sky130_fd_sc_hd__fill_2
X_3897_ hold956/X _3423_/A wire549/X VGND VGND VPWR VPWR _7382_/D sky130_fd_sc_hd__a21bo_2
XPHY_EDGE_ROW_75_Left_184 VGND VGND VPWR VPWR sky130_fd_sc_hd__decap_3
X_5567_ hold946/X _4909_/A _4870_/Y VGND VGND VPWR VPWR _7050_/D sky130_fd_sc_hd__a21o_2
XFILLER_2_318 VGND VGND VPWR VPWR sky130_fd_sc_hd__fill_2
X_7306_ _7374_/CLK _7306_/D _6586_/Y VGND VGND VPWR VPWR _7306_/Q sky130_fd_sc_hd__dfrtp_2
XFILLER_104_246 VGND VGND VPWR VPWR sky130_fd_sc_hd__decap_3
XFILLER_5_9 VGND VGND VPWR VPWR sky130_fd_sc_hd__decap_3
X_7237_ _7269_/CLK _7237_/D _6517_/Y VGND VGND VPWR VPWR _7237_/Q sky130_fd_sc_hd__dfrtp_2
X_4449_ _4403_/A _4411_/B _4448_/X VGND VGND VPWR VPWR _4761_/C sky130_fd_sc_hd__a21oi_2
X_7168_ _7362_/CLK _7168_/D _6448_/Y VGND VGND VPWR VPWR _7168_/Q sky130_fd_sc_hd__dfrtp_2
XPHY_EDGE_ROW_84_Left_193 VGND VGND VPWR VPWR sky130_fd_sc_hd__decap_3
XFILLER_98_491 VGND VGND VPWR VPWR sky130_fd_sc_hd__decap_3
XFILLER_58_355 VGND VGND VPWR VPWR sky130_fd_sc_hd__decap_3
XFILLER_85_130 VGND VGND VPWR VPWR sky130_fd_sc_hd__decap_3
X_7099_ _7356_/CLK _7099_/D _6379_/Y VGND VGND VPWR VPWR _7099_/Q sky130_fd_sc_hd__dfrtp_2
XFILLER_46_539 VGND VGND VPWR VPWR sky130_fd_sc_hd__fill_2
XFILLER_58_388 VGND VGND VPWR VPWR sky130_fd_sc_hd__decap_3
XFILLER_73_314 VGND VGND VPWR VPWR sky130_fd_sc_hd__decap_3
XFILLER_85_163 VGND VGND VPWR VPWR sky130_fd_sc_hd__decap_3
XFILLER_26_230 VGND VGND VPWR VPWR sky130_fd_sc_hd__decap_3
XFILLER_37_89 VGND VGND VPWR VPWR sky130_fd_sc_hd__decap_3
XFILLER_73_358 VGND VGND VPWR VPWR sky130_fd_sc_hd__decap_3
XFILLER_14_436 VGND VGND VPWR VPWR sky130_fd_sc_hd__decap_3
XFILLER_41_244 VGND VGND VPWR VPWR sky130_fd_sc_hd__fill_1
XFILLER_41_266 VGND VGND VPWR VPWR sky130_fd_sc_hd__decap_3
XFILLER_53_55 VGND VGND VPWR VPWR sky130_fd_sc_hd__fill_1
XFILLER_41_299 VGND VGND VPWR VPWR sky130_fd_sc_hd__decap_3
XFILLER_10_631 VGND VGND VPWR VPWR sky130_fd_sc_hd__decap_3
XFILLER_22_491 VGND VGND VPWR VPWR sky130_fd_sc_hd__decap_3
XFILLER_6_613 VGND VGND VPWR VPWR sky130_fd_sc_hd__decap_3
XFILLER_78_85 VGND VGND VPWR VPWR sky130_fd_sc_hd__decap_3
XFILLER_49_311 VGND VGND VPWR VPWR sky130_fd_sc_hd__fill_2
XFILLER_103_290 VGND VGND VPWR VPWR sky130_fd_sc_hd__decap_3
XFILLER_49_355 VGND VGND VPWR VPWR sky130_fd_sc_hd__decap_3
XFILLER_76_141 VGND VGND VPWR VPWR sky130_fd_sc_hd__decap_3
XFILLER_64_325 VGND VGND VPWR VPWR sky130_fd_sc_hd__decap_3
XFILLER_76_163 VGND VGND VPWR VPWR sky130_fd_sc_hd__fill_2
XFILLER_91_111 VGND VGND VPWR VPWR sky130_fd_sc_hd__fill_1
XFILLER_94_40 VGND VGND VPWR VPWR sky130_fd_sc_hd__decap_3
XFILLER_91_133 VGND VGND VPWR VPWR sky130_fd_sc_hd__decap_3
XFILLER_92_645 VGND VGND VPWR VPWR sky130_fd_sc_hd__decap_3
XFILLER_32_200 VGND VGND VPWR VPWR sky130_fd_sc_hd__decap_3
XFILLER_91_188 VGND VGND VPWR VPWR sky130_fd_sc_hd__decap_3
XFILLER_32_233 VGND VGND VPWR VPWR sky130_fd_sc_hd__decap_3
X_3820_ _6927_/Q _3912_/A2 _3911_/A2 _6701_/Q VGND VGND VPWR VPWR _3820_/X sky130_fd_sc_hd__a22o_2
XFILLER_20_417 VGND VGND VPWR VPWR sky130_fd_sc_hd__decap_3
XFILLER_60_586 VGND VGND VPWR VPWR sky130_fd_sc_hd__fill_2
X_3751_ _6935_/Q _3862_/A2 _3912_/B1 _6887_/Q VGND VGND VPWR VPWR _3751_/X sky130_fd_sc_hd__a22o_2
XFILLER_71_3 VGND VGND VPWR VPWR sky130_fd_sc_hd__fill_2
X_6470_ _6632_/A VGND VGND VPWR VPWR _6470_/Y sky130_fd_sc_hd__inv_2
X_3682_ _3682_/A _3682_/B VGND VGND VPWR VPWR _3682_/Y sky130_fd_sc_hd__nand2_2
X_5421_ _5421_/A0 _5135_/X _5429_/S VGND VGND VPWR VPWR _7123_/D sky130_fd_sc_hd__mux2_2
XTAP_TAPCELL_ROW_76_1108 VGND VPWR sky130_fd_sc_hd__tapvpwrvgnd_1
X_5352_ _5352_/A0 _5135_/X _7412_/A VGND VGND VPWR VPWR _7155_/D sky130_fd_sc_hd__mux2_2
X_4303_ _7320_/Q _3989_/S _4348_/B1 _7128_/Q _4302_/X VGND VGND VPWR VPWR _4303_/X
+ sky130_fd_sc_hd__a221o_2
XFILLER_87_417 VGND VGND VPWR VPWR sky130_fd_sc_hd__fill_2
X_7022_ _7405_/CLK _7022_/D _6302_/Y VGND VGND VPWR VPWR _7022_/Q sky130_fd_sc_hd__dfrtp_2
X_5283_ _3600_/A _4788_/A _5238_/X _5283_/B2 VGND VGND VPWR VPWR _7188_/D sky130_fd_sc_hd__a22o_2
XFILLER_4_82 VGND VGND VPWR VPWR sky130_fd_sc_hd__fill_2
X_4234_ _7355_/Q _4346_/B1 _4233_/X _4347_/C1 VGND VGND VPWR VPWR _4234_/X sky130_fd_sc_hd__a211o_2
XFILLER_101_249 VGND VGND VPWR VPWR sky130_fd_sc_hd__decap_3
XFILLER_68_642 VGND VGND VPWR VPWR sky130_fd_sc_hd__fill_2
XFILLER_83_601 VGND VGND VPWR VPWR sky130_fd_sc_hd__decap_3
X_4165_ _7018_/Q _4190_/A2 _4267_/A2 _7137_/Q _4164_/X VGND VGND VPWR VPWR _4165_/X
+ sky130_fd_sc_hd__a221o_2
XFILLER_28_539 VGND VGND VPWR VPWR sky130_fd_sc_hd__fill_2
XFILLER_67_152 VGND VGND VPWR VPWR sky130_fd_sc_hd__decap_3
XFILLER_67_196 VGND VGND VPWR VPWR sky130_fd_sc_hd__fill_1
XFILLER_82_144 VGND VGND VPWR VPWR sky130_fd_sc_hd__decap_3
X_4096_ _4096_/A _4096_/B VGND VGND VPWR VPWR _4633_/A sky130_fd_sc_hd__nand2_2
XTAP_TAPCELL_ROW_87_1237 VGND VPWR sky130_fd_sc_hd__tapvpwrvgnd_1
XFILLER_23_211 VGND VGND VPWR VPWR sky130_fd_sc_hd__decap_3
XFILLER_63_391 VGND VGND VPWR VPWR sky130_fd_sc_hd__fill_1
XFILLER_70_328 VGND VGND VPWR VPWR sky130_fd_sc_hd__decap_3
XFILLER_23_244 VGND VGND VPWR VPWR sky130_fd_sc_hd__decap_3
XFILLER_51_542 VGND VGND VPWR VPWR sky130_fd_sc_hd__fill_1
Xplace380 _4420_/B1 VGND VGND VPWR VPWR _4428_/B1 sky130_fd_sc_hd__buf_2
Xplace391 _5666_/A VGND VGND VPWR VPWR _4878_/A1 sky130_fd_sc_hd__buf_2
X_6806_ _6965_/CLK _6806_/D VGND VGND VPWR VPWR _6806_/Q sky130_fd_sc_hd__dfxtp_2
XFILLER_11_417 VGND VGND VPWR VPWR sky130_fd_sc_hd__decap_3
X_4998_ hold998/X _4997_/X _4998_/S VGND VGND VPWR VPWR _7262_/D sky130_fd_sc_hd__mux2_2
X_6737_ _6968_/CLK _6737_/D VGND VGND VPWR VPWR _6737_/Q sky130_fd_sc_hd__dfxtp_2
X_3949_ _7365_/Q _4493_/A0 _3958_/S VGND VGND VPWR VPWR _7365_/D sky130_fd_sc_hd__mux2_2
X_6668_ _6668_/A VGND VGND VPWR VPWR _6668_/Y sky130_fd_sc_hd__inv_2
XTAP_TAPCELL_ROW_21_478 VGND VPWR sky130_fd_sc_hd__tapvpwrvgnd_1
X_6599_ _6635_/A VGND VGND VPWR VPWR _6599_/Y sky130_fd_sc_hd__inv_2
X_5619_ _5619_/A _5622_/B VGND VGND VPWR VPWR _7018_/D sky130_fd_sc_hd__or2_2
XTAP_TAPCELL_ROW_98_1366 VGND VPWR sky130_fd_sc_hd__tapvpwrvgnd_1
XFILLER_105_511 VGND VGND VPWR VPWR sky130_fd_sc_hd__decap_3
XFILLER_105_533 VGND VGND VPWR VPWR sky130_fd_sc_hd__fill_1
XFILLER_3_6 VGND VGND VPWR VPWR sky130_fd_sc_hd__decap_3
XFILLER_3_638 VGND VGND VPWR VPWR sky130_fd_sc_hd__decap_3
XFILLER_105_555 VGND VGND VPWR VPWR sky130_fd_sc_hd__decap_3
XFILLER_2_159 VGND VGND VPWR VPWR sky130_fd_sc_hd__decap_3
XPHY_EDGE_ROW_92_Left_201 VGND VGND VPWR VPWR sky130_fd_sc_hd__decap_3
XFILLER_59_620 VGND VGND VPWR VPWR sky130_fd_sc_hd__decap_3
XFILLER_58_141 VGND VGND VPWR VPWR sky130_fd_sc_hd__decap_3
XFILLER_93_409 VGND VGND VPWR VPWR sky130_fd_sc_hd__decap_3
XFILLER_19_517 VGND VGND VPWR VPWR sky130_fd_sc_hd__fill_1
XFILLER_19_539 VGND VGND VPWR VPWR sky130_fd_sc_hd__fill_2
XFILLER_48_88 VGND VGND VPWR VPWR sky130_fd_sc_hd__decap_3
XFILLER_0_29 VGND VGND VPWR VPWR sky130_fd_sc_hd__fill_1
XFILLER_46_336 VGND VGND VPWR VPWR sky130_fd_sc_hd__decap_3
XFILLER_73_122 VGND VGND VPWR VPWR sky130_fd_sc_hd__decap_3
XFILLER_74_645 VGND VGND VPWR VPWR sky130_fd_sc_hd__decap_3
XFILLER_27_561 VGND VGND VPWR VPWR sky130_fd_sc_hd__decap_3
XFILLER_64_32 VGND VGND VPWR VPWR sky130_fd_sc_hd__decap_3
XFILLER_64_54 VGND VGND VPWR VPWR sky130_fd_sc_hd__decap_3
XFILLER_73_155 VGND VGND VPWR VPWR sky130_fd_sc_hd__decap_3
XTAP_TAPCELL_ROW_57_887 VGND VPWR sky130_fd_sc_hd__tapvpwrvgnd_1
XTAP_TAPCELL_ROW_29_567 VGND VPWR sky130_fd_sc_hd__tapvpwrvgnd_1
XFILLER_14_200 VGND VGND VPWR VPWR sky130_fd_sc_hd__decap_3
XFILLER_27_594 VGND VGND VPWR VPWR sky130_fd_sc_hd__decap_3
XFILLER_42_531 VGND VGND VPWR VPWR sky130_fd_sc_hd__fill_1
XFILLER_54_391 VGND VGND VPWR VPWR sky130_fd_sc_hd__decap_3
XFILLER_61_328 VGND VGND VPWR VPWR sky130_fd_sc_hd__decap_3
XFILLER_64_65 VGND VGND VPWR VPWR sky130_fd_sc_hd__fill_2
XTAP_TAPCELL_ROW_107_1462 VGND VPWR sky130_fd_sc_hd__tapvpwrvgnd_1
XFILLER_14_233 VGND VGND VPWR VPWR sky130_fd_sc_hd__decap_3
XFILLER_42_542 VGND VGND VPWR VPWR sky130_fd_sc_hd__fill_2
XFILLER_14_277 VGND VGND VPWR VPWR sky130_fd_sc_hd__decap_3
Xfanout70 _6524_/A VGND VGND VPWR VPWR _6557_/A sky130_fd_sc_hd__buf_2
XFILLER_10_483 VGND VGND VPWR VPWR sky130_fd_sc_hd__decap_3
XFILLER_6_421 VGND VGND VPWR VPWR sky130_fd_sc_hd__decap_3
XFILLER_6_432 VGND VGND VPWR VPWR sky130_fd_sc_hd__decap_3
XFILLER_108_371 VGND VGND VPWR VPWR sky130_fd_sc_hd__decap_3
XPHY_EDGE_ROW_108_Right_108 VGND VGND VPWR VPWR sky130_fd_sc_hd__decap_3
XFILLER_108_393 VGND VGND VPWR VPWR sky130_fd_sc_hd__decap_3
XFILLER_6_498 VGND VGND VPWR VPWR sky130_fd_sc_hd__fill_2
XTAP_TAPCELL_ROW_71_1049 VGND VPWR sky130_fd_sc_hd__tapvpwrvgnd_1
XFILLER_1_181 VGND VGND VPWR VPWR sky130_fd_sc_hd__fill_1
XFILLER_49_130 VGND VGND VPWR VPWR sky130_fd_sc_hd__decap_3
XFILLER_49_163 VGND VGND VPWR VPWR sky130_fd_sc_hd__decap_3
XFILLER_65_623 VGND VGND VPWR VPWR sky130_fd_sc_hd__decap_3
XFILLER_49_196 VGND VGND VPWR VPWR sky130_fd_sc_hd__decap_3
XFILLER_92_442 VGND VGND VPWR VPWR sky130_fd_sc_hd__decap_3
XFILLER_52_306 VGND VGND VPWR VPWR sky130_fd_sc_hd__fill_2
XFILLER_64_166 VGND VGND VPWR VPWR sky130_fd_sc_hd__decap_3
XFILLER_80_604 VGND VGND VPWR VPWR sky130_fd_sc_hd__decap_3
XFILLER_80_637 VGND VGND VPWR VPWR sky130_fd_sc_hd__decap_3
X_4921_ _4968_/A _4383_/C _4201_/X VGND VGND VPWR VPWR _4937_/B sky130_fd_sc_hd__a21bo_2
XFILLER_33_542 VGND VGND VPWR VPWR sky130_fd_sc_hd__decap_3
X_4852_ _4852_/A _5057_/A VGND VGND VPWR VPWR _5101_/A sky130_fd_sc_hd__and2_2
XFILLER_20_203 VGND VGND VPWR VPWR sky130_fd_sc_hd__decap_3
XFILLER_33_586 VGND VGND VPWR VPWR sky130_fd_sc_hd__decap_3
X_3803_ _6816_/Q _3879_/B1 _3881_/B1 _6821_/Q VGND VGND VPWR VPWR _3803_/X sky130_fd_sc_hd__a22o_2
XTAP_TAPCELL_ROW_82_1178 VGND VPWR sky130_fd_sc_hd__tapvpwrvgnd_1
XFILLER_20_236 VGND VGND VPWR VPWR sky130_fd_sc_hd__fill_1
XFILLER_20_247 VGND VGND VPWR VPWR sky130_fd_sc_hd__fill_1
X_4783_ _4646_/A _4646_/B _4827_/A VGND VGND VPWR VPWR _4829_/B sky130_fd_sc_hd__a21boi_2
X_6522_ _6686_/A VGND VGND VPWR VPWR _6522_/Y sky130_fd_sc_hd__inv_2
X_3734_ _3728_/Y _3730_/X _3732_/X _3733_/X VGND VGND VPWR VPWR _3734_/X sky130_fd_sc_hd__a22o_2
X_6453_ _6614_/A VGND VGND VPWR VPWR _6453_/Y sky130_fd_sc_hd__inv_2
X_3665_ _3665_/A _3665_/B VGND VGND VPWR VPWR _3665_/X sky130_fd_sc_hd__and2_4
XFILLER_9_292 VGND VGND VPWR VPWR sky130_fd_sc_hd__decap_3
XFILLER_9_281 VGND VGND VPWR VPWR sky130_fd_sc_hd__decap_3
X_5404_ _5404_/A0 _5040_/X _5427_/S VGND VGND VPWR VPWR _7131_/D sky130_fd_sc_hd__mux2_2
X_6384_ _6612_/A VGND VGND VPWR VPWR _6384_/Y sky130_fd_sc_hd__inv_2
X_3596_ _4295_/B _3607_/B VGND VGND VPWR VPWR _3598_/A sky130_fd_sc_hd__and2_2
XFILLER_0_608 VGND VGND VPWR VPWR sky130_fd_sc_hd__decap_3
XFILLER_102_514 VGND VGND VPWR VPWR sky130_fd_sc_hd__decap_3
XFILLER_102_536 VGND VGND VPWR VPWR sky130_fd_sc_hd__decap_3
XFILLER_87_225 VGND VGND VPWR VPWR sky130_fd_sc_hd__fill_1
X_5266_ _5266_/A0 _5011_/X _5276_/S VGND VGND VPWR VPWR _7197_/D sky130_fd_sc_hd__mux2_2
X_7005_ _7373_/CLK _7005_/D _6285_/Y VGND VGND VPWR VPWR _7005_/Q sky130_fd_sc_hd__dfrtp_2
X_4217_ _4217_/A1 _3469_/B _3449_/A _7015_/Q _3365_/A VGND VGND VPWR VPWR _4217_/X
+ sky130_fd_sc_hd__o2111a_2
XFILLER_56_612 VGND VGND VPWR VPWR sky130_fd_sc_hd__decap_3
XFILLER_28_336 VGND VGND VPWR VPWR sky130_fd_sc_hd__decap_3
XFILLER_56_645 VGND VGND VPWR VPWR sky130_fd_sc_hd__decap_3
X_4148_ _7074_/Q _4265_/B _4145_/X _4147_/X VGND VGND VPWR VPWR _4205_/B sky130_fd_sc_hd__o22a_2
XFILLER_71_626 VGND VGND VPWR VPWR sky130_fd_sc_hd__decap_3
X_4079_ _7403_/Q _4437_/B1 _4077_/X _4078_/X VGND VGND VPWR VPWR _4079_/X sky130_fd_sc_hd__a211o_2
XFILLER_55_199 VGND VGND VPWR VPWR sky130_fd_sc_hd__decap_3
XFILLER_83_497 VGND VGND VPWR VPWR sky130_fd_sc_hd__decap_3
XTAP_TAPCELL_ROW_26_537 VGND VPWR sky130_fd_sc_hd__tapvpwrvgnd_1
XFILLER_24_531 VGND VGND VPWR VPWR sky130_fd_sc_hd__fill_1
XFILLER_34_46 VGND VGND VPWR VPWR sky130_fd_sc_hd__decap_3
XFILLER_70_136 VGND VGND VPWR VPWR sky130_fd_sc_hd__decap_3
XTAP_TAPCELL_ROW_54_857 VGND VPWR sky130_fd_sc_hd__tapvpwrvgnd_1
XFILLER_34_79 VGND VGND VPWR VPWR sky130_fd_sc_hd__decap_3
XFILLER_51_383 VGND VGND VPWR VPWR sky130_fd_sc_hd__decap_3
XFILLER_11_236 VGND VGND VPWR VPWR sky130_fd_sc_hd__decap_3
XFILLER_11_269 VGND VGND VPWR VPWR sky130_fd_sc_hd__decap_3
Xclkload1 clkload1/A VGND VGND VPWR VPWR clkload1/X sky130_fd_sc_hd__clkbuf_16
XFILLER_3_446 VGND VGND VPWR VPWR sky130_fd_sc_hd__fill_2
XFILLER_105_396 VGND VGND VPWR VPWR sky130_fd_sc_hd__decap_3
XFILLER_59_65 VGND VGND VPWR VPWR sky130_fd_sc_hd__decap_3
XFILLER_78_203 VGND VGND VPWR VPWR sky130_fd_sc_hd__decap_3
XFILLER_78_236 VGND VGND VPWR VPWR sky130_fd_sc_hd__decap_3
XFILLER_78_258 VGND VGND VPWR VPWR sky130_fd_sc_hd__fill_2
XFILLER_19_303 VGND VGND VPWR VPWR sky130_fd_sc_hd__decap_3
XFILLER_47_623 VGND VGND VPWR VPWR sky130_fd_sc_hd__decap_3
XFILLER_59_461 VGND VGND VPWR VPWR sky130_fd_sc_hd__fill_1
XFILLER_101_580 VGND VGND VPWR VPWR sky130_fd_sc_hd__decap_3
XFILLER_19_325 VGND VGND VPWR VPWR sky130_fd_sc_hd__decap_3
XFILLER_46_133 VGND VGND VPWR VPWR sky130_fd_sc_hd__decap_3
XFILLER_86_280 VGND VGND VPWR VPWR sky130_fd_sc_hd__decap_3
XFILLER_93_239 VGND VGND VPWR VPWR sky130_fd_sc_hd__fill_2
XFILLER_19_358 VGND VGND VPWR VPWR sky130_fd_sc_hd__fill_1
XFILLER_46_144 VGND VGND VPWR VPWR sky130_fd_sc_hd__fill_2
XFILLER_62_615 VGND VGND VPWR VPWR sky130_fd_sc_hd__decap_3
XFILLER_74_475 VGND VGND VPWR VPWR sky130_fd_sc_hd__fill_1
XFILLER_46_188 VGND VGND VPWR VPWR sky130_fd_sc_hd__decap_3
XFILLER_15_553 VGND VGND VPWR VPWR sky130_fd_sc_hd__fill_1
XFILLER_27_391 VGND VGND VPWR VPWR sky130_fd_sc_hd__fill_1
XFILLER_61_158 VGND VGND VPWR VPWR sky130_fd_sc_hd__decap_3
XFILLER_61_169 VGND VGND VPWR VPWR sky130_fd_sc_hd__decap_3
XFILLER_15_564 VGND VGND VPWR VPWR sky130_fd_sc_hd__decap_3
XFILLER_15_597 VGND VGND VPWR VPWR sky130_fd_sc_hd__decap_3
XFILLER_30_512 VGND VGND VPWR VPWR sky130_fd_sc_hd__decap_3
XFILLER_42_361 VGND VGND VPWR VPWR sky130_fd_sc_hd__decap_3
XFILLER_91_74 VGND VGND VPWR VPWR sky130_fd_sc_hd__decap_3
XFILLER_91_85 VGND VGND VPWR VPWR sky130_fd_sc_hd__decap_3
XFILLER_30_589 VGND VGND VPWR VPWR sky130_fd_sc_hd__decap_3
XFILLER_10_280 VGND VGND VPWR VPWR sky130_fd_sc_hd__decap_3
XFILLER_6_262 VGND VGND VPWR VPWR sky130_fd_sc_hd__decap_3
Xhold708 _6969_/Q VGND VGND VPWR VPWR _6969_/D sky130_fd_sc_hd__dlygate4sd3_1
Xhold719 _6968_/Q VGND VGND VPWR VPWR _6968_/D sky130_fd_sc_hd__dlygate4sd3_1
XFILLER_97_501 VGND VGND VPWR VPWR sky130_fd_sc_hd__decap_3
XFILLER_69_225 VGND VGND VPWR VPWR sky130_fd_sc_hd__fill_2
X_5120_ _5120_/A _5120_/B VGND VGND VPWR VPWR _6984_/D sky130_fd_sc_hd__nor2_2
XFILLER_2_490 VGND VGND VPWR VPWR sky130_fd_sc_hd__decap_3
XFILLER_69_236 VGND VGND VPWR VPWR sky130_fd_sc_hd__decap_3
X_5051_ _5073_/A _5050_/X _5054_/A VGND VGND VPWR VPWR _5051_/X sky130_fd_sc_hd__a21o_2
XFILLER_97_567 VGND VGND VPWR VPWR sky130_fd_sc_hd__decap_3
XFILLER_38_612 VGND VGND VPWR VPWR sky130_fd_sc_hd__decap_3
XFILLER_97_589 VGND VGND VPWR VPWR sky130_fd_sc_hd__fill_2
XFILLER_37_122 VGND VGND VPWR VPWR sky130_fd_sc_hd__decap_3
XFILLER_38_645 VGND VGND VPWR VPWR sky130_fd_sc_hd__decap_3
XFILLER_37_166 VGND VGND VPWR VPWR sky130_fd_sc_hd__fill_2
XFILLER_80_401 VGND VGND VPWR VPWR sky130_fd_sc_hd__decap_3
XFILLER_25_328 VGND VGND VPWR VPWR sky130_fd_sc_hd__decap_3
XFILLER_37_177 VGND VGND VPWR VPWR sky130_fd_sc_hd__decap_3
XFILLER_37_199 VGND VGND VPWR VPWR sky130_fd_sc_hd__decap_3
XFILLER_53_626 VGND VGND VPWR VPWR sky130_fd_sc_hd__decap_3
XFILLER_52_136 VGND VGND VPWR VPWR sky130_fd_sc_hd__decap_3
XFILLER_52_158 VGND VGND VPWR VPWR sky130_fd_sc_hd__fill_2
XFILLER_80_445 VGND VGND VPWR VPWR sky130_fd_sc_hd__decap_3
XFILLER_40_309 VGND VGND VPWR VPWR sky130_fd_sc_hd__decap_3
X_4904_ _4903_/A _4904_/B VGND VGND VPWR VPWR _4904_/X sky130_fd_sc_hd__and2b_2
XTAP_TAPCELL_ROW_51_816 VGND VPWR sky130_fd_sc_hd__tapvpwrvgnd_1
XFILLER_21_523 VGND VGND VPWR VPWR sky130_fd_sc_hd__decap_3
X_4835_ _4467_/B _3709_/X _4832_/X _4834_/Y VGND VGND VPWR VPWR _4835_/X sky130_fd_sc_hd__a31o_2
X_4766_ _4766_/A VGND VGND VPWR VPWR _4766_/Y sky130_fd_sc_hd__inv_2
X_6505_ _6638_/A VGND VGND VPWR VPWR _6505_/Y sky130_fd_sc_hd__inv_2
XTAP_TAPCELL_ROW_31_595 VGND VPWR sky130_fd_sc_hd__tapvpwrvgnd_1
XFILLER_107_617 VGND VGND VPWR VPWR sky130_fd_sc_hd__decap_3
X_4697_ _4697_/A _6984_/Q _5670_/B VGND VGND VPWR VPWR _5120_/A sky130_fd_sc_hd__and3_2
XTAP_TAPCELL_ROW_95_1325 VGND VPWR sky130_fd_sc_hd__tapvpwrvgnd_1
XFILLER_106_138 VGND VGND VPWR VPWR sky130_fd_sc_hd__fill_2
XFILLER_20_26 VGND VGND VPWR VPWR sky130_fd_sc_hd__fill_2
X_6436_ _6630_/A VGND VGND VPWR VPWR _6436_/Y sky130_fd_sc_hd__inv_2
X_6367_ _6598_/A VGND VGND VPWR VPWR _6367_/Y sky130_fd_sc_hd__inv_2
X_3579_ _7220_/Q _4307_/A2 _3994_/S _7188_/Q VGND VGND VPWR VPWR _3579_/X sky130_fd_sc_hd__a22o_2
XFILLER_0_416 VGND VGND VPWR VPWR sky130_fd_sc_hd__decap_3
XFILLER_88_512 VGND VGND VPWR VPWR sky130_fd_sc_hd__decap_3
XFILLER_0_449 VGND VGND VPWR VPWR sky130_fd_sc_hd__fill_2
XFILLER_88_545 VGND VGND VPWR VPWR sky130_fd_sc_hd__decap_3
X_6298_ _6618_/A VGND VGND VPWR VPWR _6298_/Y sky130_fd_sc_hd__inv_2
XFILLER_29_68 VGND VGND VPWR VPWR sky130_fd_sc_hd__fill_1
XFILLER_75_217 VGND VGND VPWR VPWR sky130_fd_sc_hd__decap_3
XFILLER_88_589 VGND VGND VPWR VPWR sky130_fd_sc_hd__decap_3
X_5249_ _5249_/A0 _4878_/X _5274_/S VGND VGND VPWR VPWR _7205_/D sky130_fd_sc_hd__mux2_2
XTAP_TAPCELL_ROW_59_916 VGND VPWR sky130_fd_sc_hd__tapvpwrvgnd_1
XFILLER_29_623 VGND VGND VPWR VPWR sky130_fd_sc_hd__decap_3
XFILLER_28_133 VGND VGND VPWR VPWR sky130_fd_sc_hd__decap_3
XFILLER_28_144 VGND VGND VPWR VPWR sky130_fd_sc_hd__decap_3
XFILLER_45_12 VGND VGND VPWR VPWR sky130_fd_sc_hd__decap_3
XTAP_TAPCELL_ROW_3_265 VGND VPWR sky130_fd_sc_hd__tapvpwrvgnd_1
XFILLER_43_125 VGND VGND VPWR VPWR sky130_fd_sc_hd__fill_2
XFILLER_44_637 VGND VGND VPWR VPWR sky130_fd_sc_hd__decap_3
XFILLER_56_486 VGND VGND VPWR VPWR sky130_fd_sc_hd__decap_3
XFILLER_71_401 VGND VGND VPWR VPWR sky130_fd_sc_hd__decap_3
XTAP_TAPCELL_ROW_39_684 VGND VPWR sky130_fd_sc_hd__tapvpwrvgnd_1
XFILLER_43_147 VGND VGND VPWR VPWR sky130_fd_sc_hd__fill_2
XFILLER_43_158 VGND VGND VPWR VPWR sky130_fd_sc_hd__fill_2
XFILLER_71_467 VGND VGND VPWR VPWR sky130_fd_sc_hd__decap_3
XTAP_TAPCELL_ROW_104_1432 VGND VPWR sky130_fd_sc_hd__tapvpwrvgnd_1
XFILLER_12_545 VGND VGND VPWR VPWR sky130_fd_sc_hd__fill_1
XFILLER_51_191 VGND VGND VPWR VPWR sky130_fd_sc_hd__decap_3
XFILLER_12_567 VGND VGND VPWR VPWR sky130_fd_sc_hd__decap_3
XFILLER_12_589 VGND VGND VPWR VPWR sky130_fd_sc_hd__decap_3
XFILLER_61_66 VGND VGND VPWR VPWR sky130_fd_sc_hd__decap_3
XPHY_EDGE_ROW_20_Left_129 VGND VGND VPWR VPWR sky130_fd_sc_hd__decap_3
XFILLER_3_210 VGND VGND VPWR VPWR sky130_fd_sc_hd__decap_3
XFILLER_3_243 VGND VGND VPWR VPWR sky130_fd_sc_hd__decap_3
XFILLER_98_309 VGND VGND VPWR VPWR sky130_fd_sc_hd__decap_3
XFILLER_3_265 VGND VGND VPWR VPWR sky130_fd_sc_hd__decap_3
XFILLER_79_523 VGND VGND VPWR VPWR sky130_fd_sc_hd__decap_3
XFILLER_79_556 VGND VGND VPWR VPWR sky130_fd_sc_hd__decap_3
XFILLER_79_567 VGND VGND VPWR VPWR sky130_fd_sc_hd__fill_1
XFILLER_66_206 VGND VGND VPWR VPWR sky130_fd_sc_hd__decap_3
XFILLER_79_589 VGND VGND VPWR VPWR sky130_fd_sc_hd__decap_3
XFILLER_94_515 VGND VGND VPWR VPWR sky130_fd_sc_hd__decap_3
XFILLER_86_85 VGND VGND VPWR VPWR sky130_fd_sc_hd__decap_3
XFILLER_19_155 VGND VGND VPWR VPWR sky130_fd_sc_hd__decap_3
XFILLER_47_442 VGND VGND VPWR VPWR sky130_fd_sc_hd__decap_3
XFILLER_74_250 VGND VGND VPWR VPWR sky130_fd_sc_hd__fill_2
XFILLER_35_615 VGND VGND VPWR VPWR sky130_fd_sc_hd__fill_1
XFILLER_35_626 VGND VGND VPWR VPWR sky130_fd_sc_hd__decap_3
XFILLER_47_486 VGND VGND VPWR VPWR sky130_fd_sc_hd__decap_3
XFILLER_34_147 VGND VGND VPWR VPWR sky130_fd_sc_hd__decap_3
XFILLER_74_294 VGND VGND VPWR VPWR sky130_fd_sc_hd__decap_3
XFILLER_15_372 VGND VGND VPWR VPWR sky130_fd_sc_hd__decap_3
XFILLER_50_629 VGND VGND VPWR VPWR sky130_fd_sc_hd__decap_3
XFILLER_62_489 VGND VGND VPWR VPWR sky130_fd_sc_hd__decap_3
XFILLER_42_191 VGND VGND VPWR VPWR sky130_fd_sc_hd__decap_3
X_4620_ _4620_/A _5003_/A _4620_/C _5032_/A VGND VGND VPWR VPWR _4624_/B sky130_fd_sc_hd__and4_4
XFILLER_7_582 VGND VGND VPWR VPWR sky130_fd_sc_hd__decap_3
X_7270_ _7366_/CLK _7270_/D _6550_/Y VGND VGND VPWR VPWR _7270_/Q sky130_fd_sc_hd__dfrtp_2
X_4482_ _7338_/Q _7306_/Q _4501_/S VGND VGND VPWR VPWR _7338_/D sky130_fd_sc_hd__mux2_2
X_3502_ _3502_/A _3502_/B _3485_/C VGND VGND VPWR VPWR _3502_/X sky130_fd_sc_hd__or3b_2
XFILLER_103_108 VGND VGND VPWR VPWR sky130_fd_sc_hd__decap_3
XFILLER_106_29 VGND VGND VPWR VPWR sky130_fd_sc_hd__decap_3
X_5103_ _5146_/B1 _5047_/Y _5099_/X _5102_/X VGND VGND VPWR VPWR _5660_/C sky130_fd_sc_hd__a31oi_2
X_3364_ _3362_/X _5294_/B _3371_/A VGND VGND VPWR VPWR _3399_/B sky130_fd_sc_hd__a21boi_2
XTAP_TAPCELL_ROW_90_1266 VGND VPWR sky130_fd_sc_hd__tapvpwrvgnd_1
XFILLER_97_320 VGND VGND VPWR VPWR sky130_fd_sc_hd__decap_3
Xhold1205 _7123_/Q VGND VGND VPWR VPWR _5421_/A0 sky130_fd_sc_hd__dlygate4sd3_1
Xhold1216 _3964_/X VGND VGND VPWR VPWR _7358_/D sky130_fd_sc_hd__dlygate4sd3_1
XFILLER_97_375 VGND VGND VPWR VPWR sky130_fd_sc_hd__decap_3
XFILLER_97_364 VGND VGND VPWR VPWR sky130_fd_sc_hd__decap_3
XFILLER_57_228 VGND VGND VPWR VPWR sky130_fd_sc_hd__decap_3
XFILLER_85_559 VGND VGND VPWR VPWR sky130_fd_sc_hd__fill_1
X_5034_ _4811_/C _5031_/X _5032_/Y _4969_/B _5033_/X VGND VGND VPWR VPWR _5658_/B
+ sky130_fd_sc_hd__a221o_2
XFILLER_38_442 VGND VGND VPWR VPWR sky130_fd_sc_hd__fill_1
XFILLER_38_464 VGND VGND VPWR VPWR sky130_fd_sc_hd__decap_3
XFILLER_72_209 VGND VGND VPWR VPWR sky130_fd_sc_hd__decap_3
XFILLER_26_626 VGND VGND VPWR VPWR sky130_fd_sc_hd__decap_3
XFILLER_38_475 VGND VGND VPWR VPWR sky130_fd_sc_hd__fill_1
XTAP_TAPCELL_ROW_0_235 VGND VPWR sky130_fd_sc_hd__tapvpwrvgnd_1
XTAP_TAPCELL_ROW_0_224 VGND VPWR sky130_fd_sc_hd__tapvpwrvgnd_1
XFILLER_53_434 VGND VGND VPWR VPWR sky130_fd_sc_hd__decap_3
X_6985_ _7383_/CLK _6985_/D _6265_/Y VGND VGND VPWR VPWR _6985_/Q sky130_fd_sc_hd__dfrtp_2
XTAP_TAPCELL_ROW_36_654 VGND VPWR sky130_fd_sc_hd__tapvpwrvgnd_1
XTAP_TAPCELL_ROW_36_643 VGND VPWR sky130_fd_sc_hd__tapvpwrvgnd_1
XFILLER_25_169 VGND VGND VPWR VPWR sky130_fd_sc_hd__decap_3
XFILLER_41_629 VGND VGND VPWR VPWR sky130_fd_sc_hd__decap_3
XFILLER_53_478 VGND VGND VPWR VPWR sky130_fd_sc_hd__decap_3
XFILLER_80_253 VGND VGND VPWR VPWR sky130_fd_sc_hd__decap_3
XTAP_TAPCELL_ROW_64_974 VGND VPWR sky130_fd_sc_hd__tapvpwrvgnd_1
XFILLER_21_320 VGND VGND VPWR VPWR sky130_fd_sc_hd__decap_3
XFILLER_40_128 VGND VGND VPWR VPWR sky130_fd_sc_hd__decap_3
XFILLER_80_297 VGND VGND VPWR VPWR sky130_fd_sc_hd__decap_3
X_4818_ _7002_/Q _4834_/A VGND VGND VPWR VPWR _4818_/Y sky130_fd_sc_hd__nand2_2
XFILLER_5_508 VGND VGND VPWR VPWR sky130_fd_sc_hd__fill_2
X_4749_ _7006_/Q _4749_/B VGND VGND VPWR VPWR _4750_/C sky130_fd_sc_hd__nor2_2
XFILLER_103_6 VGND VGND VPWR VPWR sky130_fd_sc_hd__decap_3
XFILLER_107_458 VGND VGND VPWR VPWR sky130_fd_sc_hd__decap_3
X_6419_ _6645_/A VGND VGND VPWR VPWR _6419_/Y sky130_fd_sc_hd__inv_2
X_7399_ _7405_/CLK _7399_/D _6679_/Y VGND VGND VPWR VPWR _7399_/Q sky130_fd_sc_hd__dfrtp_2
XTAP_TAPCELL_ROW_8_324 VGND VPWR sky130_fd_sc_hd__tapvpwrvgnd_1
XFILLER_103_620 VGND VGND VPWR VPWR sky130_fd_sc_hd__decap_3
XFILLER_88_342 VGND VGND VPWR VPWR sky130_fd_sc_hd__decap_3
XFILLER_102_141 VGND VGND VPWR VPWR sky130_fd_sc_hd__decap_3
XFILLER_48_206 VGND VGND VPWR VPWR sky130_fd_sc_hd__decap_3
XFILLER_88_375 VGND VGND VPWR VPWR sky130_fd_sc_hd__decap_3
XFILLER_102_174 VGND VGND VPWR VPWR sky130_fd_sc_hd__decap_3
XFILLER_76_548 VGND VGND VPWR VPWR sky130_fd_sc_hd__fill_2
XFILLER_76_559 VGND VGND VPWR VPWR sky130_fd_sc_hd__fill_2
XFILLER_29_442 VGND VGND VPWR VPWR sky130_fd_sc_hd__fill_2
XFILLER_17_615 VGND VGND VPWR VPWR sky130_fd_sc_hd__fill_1
XFILLER_17_626 VGND VGND VPWR VPWR sky130_fd_sc_hd__decap_3
XFILLER_56_250 VGND VGND VPWR VPWR sky130_fd_sc_hd__fill_2
XFILLER_91_529 VGND VGND VPWR VPWR sky130_fd_sc_hd__decap_3
XFILLER_16_136 VGND VGND VPWR VPWR sky130_fd_sc_hd__decap_3
XFILLER_16_147 VGND VGND VPWR VPWR sky130_fd_sc_hd__fill_2
XFILLER_32_607 VGND VGND VPWR VPWR sky130_fd_sc_hd__decap_3
XFILLER_44_489 VGND VGND VPWR VPWR sky130_fd_sc_hd__decap_3
XFILLER_71_253 VGND VGND VPWR VPWR sky130_fd_sc_hd__decap_3
XFILLER_8_302 VGND VGND VPWR VPWR sky130_fd_sc_hd__fill_1
XFILLER_8_324 VGND VGND VPWR VPWR sky130_fd_sc_hd__decap_3
XFILLER_8_368 VGND VGND VPWR VPWR sky130_fd_sc_hd__fill_1
XFILLER_8_379 VGND VGND VPWR VPWR sky130_fd_sc_hd__decap_3
XFILLER_99_607 VGND VGND VPWR VPWR sky130_fd_sc_hd__decap_3
XFILLER_4_563 VGND VGND VPWR VPWR sky130_fd_sc_hd__decap_3
XFILLER_99_629 VGND VGND VPWR VPWR sky130_fd_sc_hd__decap_3
XFILLER_79_331 VGND VGND VPWR VPWR sky130_fd_sc_hd__decap_3
XFILLER_39_217 VGND VGND VPWR VPWR sky130_fd_sc_hd__decap_3
XFILLER_39_228 VGND VGND VPWR VPWR sky130_fd_sc_hd__decap_3
XFILLER_67_559 VGND VGND VPWR VPWR sky130_fd_sc_hd__fill_1
XFILLER_82_518 VGND VGND VPWR VPWR sky130_fd_sc_hd__decap_3
XFILLER_35_412 VGND VGND VPWR VPWR sky130_fd_sc_hd__decap_3
XFILLER_75_581 VGND VGND VPWR VPWR sky130_fd_sc_hd__fill_2
XFILLER_22_106 VGND VGND VPWR VPWR sky130_fd_sc_hd__fill_2
XFILLER_23_607 VGND VGND VPWR VPWR sky130_fd_sc_hd__decap_3
XFILLER_23_629 VGND VGND VPWR VPWR sky130_fd_sc_hd__decap_3
XFILLER_50_404 VGND VGND VPWR VPWR sky130_fd_sc_hd__decap_3
XFILLER_62_264 VGND VGND VPWR VPWR sky130_fd_sc_hd__fill_1
XFILLER_90_573 VGND VGND VPWR VPWR sky130_fd_sc_hd__fill_2
X_6770_ _6966_/CLK _6770_/D VGND VGND VPWR VPWR _6770_/Q sky130_fd_sc_hd__dfxtp_2
XFILLER_22_128 VGND VGND VPWR VPWR sky130_fd_sc_hd__decap_3
XFILLER_62_286 VGND VGND VPWR VPWR sky130_fd_sc_hd__fill_1
XFILLER_62_297 VGND VGND VPWR VPWR sky130_fd_sc_hd__fill_1
XFILLER_90_595 VGND VGND VPWR VPWR sky130_fd_sc_hd__decap_3
X_5721_ _7366_/Q hold949/X _5721_/S VGND VGND VPWR VPWR _6710_/D sky130_fd_sc_hd__mux2_2
XTAP_TAPCELL_ROW_61_933 VGND VPWR sky130_fd_sc_hd__tapvpwrvgnd_1
XTAP_TAPCELL_ROW_33_613 VGND VPWR sky130_fd_sc_hd__tapvpwrvgnd_1
X_5652_ _5664_/A VGND VGND VPWR VPWR _5652_/Y sky130_fd_sc_hd__inv_2
XFILLER_30_194 VGND VGND VPWR VPWR sky130_fd_sc_hd__fill_2
X_5583_ _5583_/A0 _5094_/X _5595_/B VGND VGND VPWR VPWR _7037_/D sky130_fd_sc_hd__mux2_2
X_4603_ hold977/X _4595_/B _3487_/X VGND VGND VPWR VPWR _7279_/D sky130_fd_sc_hd__a21o_2
XTAP_TAPCELL_ROW_79_1139 VGND VPWR sky130_fd_sc_hd__tapvpwrvgnd_1
XTAP_TAPCELL_ROW_13_381 VGND VPWR sky130_fd_sc_hd__tapvpwrvgnd_1
XFILLER_7_71 VGND VGND VPWR VPWR sky130_fd_sc_hd__decap_3
X_7322_ _7356_/CLK _7322_/D _6602_/Y VGND VGND VPWR VPWR _7322_/Q sky130_fd_sc_hd__dfrtp_2
X_4534_ _4534_/A0 _7280_/Q _4534_/S VGND VGND VPWR VPWR _7312_/D sky130_fd_sc_hd__mux2_2
XFILLER_104_417 VGND VGND VPWR VPWR sky130_fd_sc_hd__decap_3
X_7253_ _7349_/CLK _7253_/D _6533_/Y VGND VGND VPWR VPWR _7253_/Q sky130_fd_sc_hd__dfrtp_2
X_4465_ _5655_/B _5655_/C VGND VGND VPWR VPWR _5650_/A sky130_fd_sc_hd__nor2_2
X_7184_ _7376_/CLK _7184_/D _6464_/Y VGND VGND VPWR VPWR _7184_/Q sky130_fd_sc_hd__dfrtp_2
X_4396_ _4396_/A _4444_/B VGND VGND VPWR VPWR _4648_/A sky130_fd_sc_hd__nor2_2
XFILLER_98_640 VGND VGND VPWR VPWR sky130_fd_sc_hd__decap_3
X_3347_ _5640_/B _3509_/B VGND VGND VPWR VPWR _3420_/A sky130_fd_sc_hd__or2_2
XFILLER_97_161 VGND VGND VPWR VPWR sky130_fd_sc_hd__decap_3
XFILLER_100_645 VGND VGND VPWR VPWR sky130_fd_sc_hd__decap_3
Xhold1002 _7206_/Q VGND VGND VPWR VPWR _5247_/A0 sky130_fd_sc_hd__dlygate4sd3_1
Xhold1013 _7277_/Q VGND VGND VPWR VPWR _4735_/A0 sky130_fd_sc_hd__dlygate4sd3_1
Xhold1024 _7265_/Q VGND VGND VPWR VPWR _4946_/A0 sky130_fd_sc_hd__dlygate4sd3_1
XFILLER_45_209 VGND VGND VPWR VPWR sky130_fd_sc_hd__decap_3
XFILLER_85_367 VGND VGND VPWR VPWR sky130_fd_sc_hd__decap_3
Xhold1035 _7278_/Q VGND VGND VPWR VPWR _4718_/A0 sky130_fd_sc_hd__dlygate4sd3_1
Xhold1046 _7273_/Q VGND VGND VPWR VPWR _4807_/A0 sky130_fd_sc_hd__dlygate4sd3_1
Xhold1057 _7318_/Q VGND VGND VPWR VPWR _4522_/A0 sky130_fd_sc_hd__dlygate4sd3_1
X_5017_ _5018_/A _5017_/B VGND VGND VPWR VPWR _5017_/Y sky130_fd_sc_hd__xnor2_2
XFILLER_66_570 VGND VGND VPWR VPWR sky130_fd_sc_hd__decap_3
Xhold1068 _7227_/Q VGND VGND VPWR VPWR _5203_/A sky130_fd_sc_hd__dlygate4sd3_1
Xhold1079 _7051_/Q VGND VGND VPWR VPWR _5566_/A1 sky130_fd_sc_hd__dlygate4sd3_1
XFILLER_38_283 VGND VGND VPWR VPWR sky130_fd_sc_hd__decap_3
XFILLER_53_220 VGND VGND VPWR VPWR sky130_fd_sc_hd__decap_3
XFILLER_14_607 VGND VGND VPWR VPWR sky130_fd_sc_hd__decap_3
XFILLER_53_264 VGND VGND VPWR VPWR sky130_fd_sc_hd__decap_3
XFILLER_81_551 VGND VGND VPWR VPWR sky130_fd_sc_hd__fill_1
XFILLER_81_584 VGND VGND VPWR VPWR sky130_fd_sc_hd__fill_1
X_6968_ _6968_/CLK _6968_/D VGND VGND VPWR VPWR _6968_/Q sky130_fd_sc_hd__dfxtp_2
XFILLER_22_640 VGND VGND VPWR VPWR sky130_fd_sc_hd__decap_3
XFILLER_42_24 VGND VGND VPWR VPWR sky130_fd_sc_hd__decap_3
X_6899_ clkload3/A _6899_/D VGND VGND VPWR VPWR _6899_/Q sky130_fd_sc_hd__dfxtp_2
XFILLER_21_172 VGND VGND VPWR VPWR sky130_fd_sc_hd__decap_3
XFILLER_5_327 VGND VGND VPWR VPWR sky130_fd_sc_hd__decap_3
XFILLER_101_3 VGND VGND VPWR VPWR sky130_fd_sc_hd__decap_3
XFILLER_1_511 VGND VGND VPWR VPWR sky130_fd_sc_hd__decap_3
XFILLER_1_544 VGND VGND VPWR VPWR sky130_fd_sc_hd__decap_3
Xhold880 _7062_/Q VGND VGND VPWR VPWR _7062_/D sky130_fd_sc_hd__dlygate4sd3_1
Xhold891 _7075_/Q VGND VGND VPWR VPWR _7075_/D sky130_fd_sc_hd__dlygate4sd3_1
XFILLER_103_461 VGND VGND VPWR VPWR sky130_fd_sc_hd__fill_2
XFILLER_107_72 VGND VGND VPWR VPWR sky130_fd_sc_hd__decap_3
XFILLER_1_588 VGND VGND VPWR VPWR sky130_fd_sc_hd__fill_1
XFILLER_1_599 VGND VGND VPWR VPWR sky130_fd_sc_hd__decap_3
XFILLER_49_537 VGND VGND VPWR VPWR sky130_fd_sc_hd__fill_2
XFILLER_76_334 VGND VGND VPWR VPWR sky130_fd_sc_hd__decap_3
XFILLER_88_172 VGND VGND VPWR VPWR sky130_fd_sc_hd__decap_3
XFILLER_88_194 VGND VGND VPWR VPWR sky130_fd_sc_hd__fill_2
XFILLER_76_389 VGND VGND VPWR VPWR sky130_fd_sc_hd__decap_3
XFILLER_29_294 VGND VGND VPWR VPWR sky130_fd_sc_hd__decap_3
XFILLER_57_592 VGND VGND VPWR VPWR sky130_fd_sc_hd__decap_3
XFILLER_83_20 VGND VGND VPWR VPWR sky130_fd_sc_hd__decap_3
XFILLER_91_337 VGND VGND VPWR VPWR sky130_fd_sc_hd__decap_3
XFILLER_91_359 VGND VGND VPWR VPWR sky130_fd_sc_hd__decap_3
XTAP_TAPCELL_ROW_67_1010 VGND VPWR sky130_fd_sc_hd__tapvpwrvgnd_1
XPHY_EDGE_ROW_103_Left_212 VGND VGND VPWR VPWR sky130_fd_sc_hd__decap_3
XFILLER_17_489 VGND VGND VPWR VPWR sky130_fd_sc_hd__decap_3
XFILLER_44_253 VGND VGND VPWR VPWR sky130_fd_sc_hd__decap_3
XFILLER_44_297 VGND VGND VPWR VPWR sky130_fd_sc_hd__fill_2
XFILLER_9_600 VGND VGND VPWR VPWR sky130_fd_sc_hd__decap_3
XFILLER_12_150 VGND VGND VPWR VPWR sky130_fd_sc_hd__decap_3
XFILLER_9_644 VGND VGND VPWR VPWR sky130_fd_sc_hd__decap_3
XFILLER_12_194 VGND VGND VPWR VPWR sky130_fd_sc_hd__fill_2
XFILLER_66_6 VGND VGND VPWR VPWR sky130_fd_sc_hd__decap_3
XTAP_TAPCELL_ROW_10_351 VGND VPWR sky130_fd_sc_hd__tapvpwrvgnd_1
X_4250_ _7101_/Q _4335_/B1 _4352_/B1 _7165_/Q VGND VGND VPWR VPWR _4250_/X sky130_fd_sc_hd__a22o_2
X_4181_ _7200_/Q _3966_/S _4354_/B1 _7392_/Q VGND VGND VPWR VPWR _4181_/X sky130_fd_sc_hd__a22o_2
XFILLER_79_161 VGND VGND VPWR VPWR sky130_fd_sc_hd__decap_3
XFILLER_79_172 VGND VGND VPWR VPWR sky130_fd_sc_hd__decap_3
XFILLER_95_621 VGND VGND VPWR VPWR sky130_fd_sc_hd__decap_3
XFILLER_95_610 VGND VGND VPWR VPWR sky130_fd_sc_hd__decap_3
XFILLER_55_529 VGND VGND VPWR VPWR sky130_fd_sc_hd__decap_3
XFILLER_82_304 VGND VGND VPWR VPWR sky130_fd_sc_hd__decap_3
XFILLER_82_315 VGND VGND VPWR VPWR sky130_fd_sc_hd__decap_3
XFILLER_94_175 VGND VGND VPWR VPWR sky130_fd_sc_hd__decap_3
XFILLER_63_573 VGND VGND VPWR VPWR sky130_fd_sc_hd__decap_3
X_6822_ clkload6/A _6822_/D VGND VGND VPWR VPWR _6822_/Q sky130_fd_sc_hd__dfxtp_2
XTAP_TAPCELL_ROW_46_760 VGND VPWR sky130_fd_sc_hd__tapvpwrvgnd_1
XTAP_TAPCELL_ROW_18_440 VGND VPWR sky130_fd_sc_hd__tapvpwrvgnd_1
XFILLER_50_245 VGND VGND VPWR VPWR sky130_fd_sc_hd__decap_3
X_6753_ _6963_/CLK _6753_/D VGND VGND VPWR VPWR _6753_/Q sky130_fd_sc_hd__dfxtp_2
X_6684_ _6684_/A VGND VGND VPWR VPWR _6684_/Y sky130_fd_sc_hd__inv_2
X_3896_ _3880_/X _3885_/X _3895_/X _3896_/B1 VGND VGND VPWR VPWR _3896_/Y sky130_fd_sc_hd__o31ai_1
XFILLER_12_49 VGND VGND VPWR VPWR sky130_fd_sc_hd__decap_3
X_5566_ _5566_/A1 _4777_/A _4860_/Y VGND VGND VPWR VPWR _7051_/D sky130_fd_sc_hd__o21a_2
XFILLER_104_203 VGND VGND VPWR VPWR sky130_fd_sc_hd__decap_3
X_7305_ _7373_/CLK _7305_/D _6585_/Y VGND VGND VPWR VPWR _7305_/Q sky130_fd_sc_hd__dfrtp_2
X_4517_ _4517_/A0 _7289_/Q _4520_/S VGND VGND VPWR VPWR _7321_/D sky130_fd_sc_hd__mux2_2
X_7236_ _7362_/CLK _7236_/D _6516_/Y VGND VGND VPWR VPWR _7236_/Q sky130_fd_sc_hd__dfrtp_2
X_4448_ _4444_/X _4447_/Y _4413_/A VGND VGND VPWR VPWR _4448_/X sky130_fd_sc_hd__o21a_2
XFILLER_58_312 VGND VGND VPWR VPWR sky130_fd_sc_hd__decap_3
X_7167_ _7362_/CLK _7167_/D _6447_/Y VGND VGND VPWR VPWR _7167_/Q sky130_fd_sc_hd__dfrtp_2
X_4379_ _4938_/B _4379_/B VGND VGND VPWR VPWR _4937_/A sky130_fd_sc_hd__or2_2
XFILLER_98_470 VGND VGND VPWR VPWR sky130_fd_sc_hd__decap_3
XFILLER_100_453 VGND VGND VPWR VPWR sky130_fd_sc_hd__fill_2
XFILLER_58_345 VGND VGND VPWR VPWR sky130_fd_sc_hd__decap_3
XFILLER_85_142 VGND VGND VPWR VPWR sky130_fd_sc_hd__decap_3
X_7098_ _7352_/CLK _7098_/D _6378_/Y VGND VGND VPWR VPWR _7098_/Q sky130_fd_sc_hd__dfrtp_2
XFILLER_100_486 VGND VGND VPWR VPWR sky130_fd_sc_hd__fill_1
XFILLER_18_209 VGND VGND VPWR VPWR sky130_fd_sc_hd__decap_3
XFILLER_46_529 VGND VGND VPWR VPWR sky130_fd_sc_hd__decap_3
XFILLER_73_326 VGND VGND VPWR VPWR sky130_fd_sc_hd__decap_3
XFILLER_54_540 VGND VGND VPWR VPWR sky130_fd_sc_hd__fill_2
XFILLER_73_337 VGND VGND VPWR VPWR sky130_fd_sc_hd__decap_3
XFILLER_26_242 VGND VGND VPWR VPWR sky130_fd_sc_hd__decap_3
XFILLER_26_253 VGND VGND VPWR VPWR sky130_fd_sc_hd__decap_3
XFILLER_26_297 VGND VGND VPWR VPWR sky130_fd_sc_hd__decap_3
XFILLER_41_201 VGND VGND VPWR VPWR sky130_fd_sc_hd__decap_3
XFILLER_10_610 VGND VGND VPWR VPWR sky130_fd_sc_hd__decap_3
XFILLER_41_278 VGND VGND VPWR VPWR sky130_fd_sc_hd__fill_2
XFILLER_5_113 VGND VGND VPWR VPWR sky130_fd_sc_hd__decap_3
XFILLER_6_625 VGND VGND VPWR VPWR sky130_fd_sc_hd__decap_3
XFILLER_108_564 VGND VGND VPWR VPWR sky130_fd_sc_hd__decap_3
XFILLER_1_352 VGND VGND VPWR VPWR sky130_fd_sc_hd__fill_2
XFILLER_77_610 VGND VGND VPWR VPWR sky130_fd_sc_hd__decap_3
XFILLER_77_632 VGND VGND VPWR VPWR sky130_fd_sc_hd__decap_3
XFILLER_89_492 VGND VGND VPWR VPWR sky130_fd_sc_hd__fill_1
XFILLER_49_367 VGND VGND VPWR VPWR sky130_fd_sc_hd__decap_3
XFILLER_64_315 VGND VGND VPWR VPWR sky130_fd_sc_hd__fill_2
XFILLER_91_101 VGND VGND VPWR VPWR sky130_fd_sc_hd__fill_1
XFILLER_92_613 VGND VGND VPWR VPWR sky130_fd_sc_hd__fill_2
XFILLER_94_63 VGND VGND VPWR VPWR sky130_fd_sc_hd__decap_3
XFILLER_64_337 VGND VGND VPWR VPWR sky130_fd_sc_hd__fill_1
XFILLER_64_359 VGND VGND VPWR VPWR sky130_fd_sc_hd__decap_3
XFILLER_76_197 VGND VGND VPWR VPWR sky130_fd_sc_hd__decap_3
XFILLER_91_145 VGND VGND VPWR VPWR sky130_fd_sc_hd__decap_3
XFILLER_94_85 VGND VGND VPWR VPWR sky130_fd_sc_hd__decap_3
XFILLER_17_231 VGND VGND VPWR VPWR sky130_fd_sc_hd__decap_3
XFILLER_27_90 VGND VGND VPWR VPWR sky130_fd_sc_hd__decap_3
XFILLER_45_551 VGND VGND VPWR VPWR sky130_fd_sc_hd__decap_3
XFILLER_45_573 VGND VGND VPWR VPWR sky130_fd_sc_hd__decap_3
XFILLER_91_167 VGND VGND VPWR VPWR sky130_fd_sc_hd__fill_1
XFILLER_91_178 VGND VGND VPWR VPWR sky130_fd_sc_hd__decap_3
XFILLER_32_212 VGND VGND VPWR VPWR sky130_fd_sc_hd__decap_3
XTAP_TAPCELL_ROW_15_410 VGND VPWR sky130_fd_sc_hd__tapvpwrvgnd_1
XFILLER_32_245 VGND VGND VPWR VPWR sky130_fd_sc_hd__decap_3
XTAP_TAPCELL_ROW_43_730 VGND VPWR sky130_fd_sc_hd__tapvpwrvgnd_1
XFILLER_20_429 VGND VGND VPWR VPWR sky130_fd_sc_hd__decap_3
X_3750_ _3750_/A1 _3857_/A2 _3749_/Y VGND VGND VPWR VPWR _7398_/D sky130_fd_sc_hd__a21bo_2
XFILLER_9_430 VGND VGND VPWR VPWR sky130_fd_sc_hd__fill_1
X_3681_ _3674_/Y _3913_/A2 _3884_/B1 _3676_/Y _3680_/X VGND VGND VPWR VPWR _3682_/B
+ sky130_fd_sc_hd__a221o_2
XFILLER_9_474 VGND VGND VPWR VPWR sky130_fd_sc_hd__decap_3
XTAP_TAPCELL_ROW_76_1109 VGND VPWR sky130_fd_sc_hd__tapvpwrvgnd_1
X_5282_ hold954/X _5238_/X _3610_/Y VGND VGND VPWR VPWR _7189_/D sky130_fd_sc_hd__a21o_2
X_4302_ _7224_/Q _3377_/X _4338_/C1 _4301_/X VGND VGND VPWR VPWR _4302_/X sky130_fd_sc_hd__a211o_2
X_7021_ _7392_/CLK _7021_/D _6301_/Y VGND VGND VPWR VPWR _7021_/Q sky130_fd_sc_hd__dfrtp_2
X_4233_ _7323_/Q _3989_/S _4495_/S _7291_/Q VGND VGND VPWR VPWR _4233_/X sky130_fd_sc_hd__a22o_2
XFILLER_101_206 VGND VGND VPWR VPWR sky130_fd_sc_hd__decap_3
XFILLER_101_228 VGND VGND VPWR VPWR sky130_fd_sc_hd__decap_3
XFILLER_95_440 VGND VGND VPWR VPWR sky130_fd_sc_hd__fill_1
X_4164_ _7105_/Q _4434_/A2 _4416_/B1 _7169_/Q VGND VGND VPWR VPWR _4164_/X sky130_fd_sc_hd__a22o_2
XFILLER_67_164 VGND VGND VPWR VPWR sky130_fd_sc_hd__decap_3
XFILLER_67_175 VGND VGND VPWR VPWR sky130_fd_sc_hd__decap_3
X_4095_ _4095_/A _4210_/B VGND VGND VPWR VPWR _4096_/B sky130_fd_sc_hd__nand2_2
XFILLER_55_337 VGND VGND VPWR VPWR sky130_fd_sc_hd__decap_3
XTAP_TAPCELL_ROW_87_1238 VGND VPWR sky130_fd_sc_hd__tapvpwrvgnd_1
XFILLER_23_256 VGND VGND VPWR VPWR sky130_fd_sc_hd__decap_3
Xplace381 _4341_/B1 VGND VGND VPWR VPWR _4420_/B1 sky130_fd_sc_hd__buf_2
Xplace370 _3896_/B1 VGND VGND VPWR VPWR _3867_/B1 sky130_fd_sc_hd__buf_2
X_6805_ _6943_/CLK _6805_/D VGND VGND VPWR VPWR _6805_/Q sky130_fd_sc_hd__dfxtp_2
XFILLER_11_429 VGND VGND VPWR VPWR sky130_fd_sc_hd__decap_3
XFILLER_51_587 VGND VGND VPWR VPWR sky130_fd_sc_hd__fill_1
Xplace392 _5642_/A VGND VGND VPWR VPWR _5666_/A sky130_fd_sc_hd__buf_2
X_6736_ clkload3/A _6736_/D VGND VGND VPWR VPWR _6736_/Q sky130_fd_sc_hd__dfxtp_2
X_4997_ _5666_/A _6992_/D _4983_/X _4996_/X VGND VGND VPWR VPWR _4997_/X sky130_fd_sc_hd__a211o_2
X_6667_ _6667_/A VGND VGND VPWR VPWR _6667_/Y sky130_fd_sc_hd__inv_2
X_3879_ _6747_/Q _3888_/A2 _3879_/B1 _6735_/Q _3878_/X VGND VGND VPWR VPWR _3879_/X
+ sky130_fd_sc_hd__a221o_2
XTAP_TAPCELL_ROW_21_479 VGND VPWR sky130_fd_sc_hd__tapvpwrvgnd_1
X_6598_ _6598_/A VGND VGND VPWR VPWR _6598_/Y sky130_fd_sc_hd__inv_2
XTAP_TAPCELL_ROW_98_1367 VGND VPWR sky130_fd_sc_hd__tapvpwrvgnd_1
XTAP_TAPCELL_ROW_98_1356 VGND VPWR sky130_fd_sc_hd__tapvpwrvgnd_1
XFILLER_3_606 VGND VGND VPWR VPWR sky130_fd_sc_hd__decap_3
XFILLER_3_617 VGND VGND VPWR VPWR sky130_fd_sc_hd__decap_3
XFILLER_105_523 VGND VGND VPWR VPWR sky130_fd_sc_hd__fill_2
XFILLER_2_105 VGND VGND VPWR VPWR sky130_fd_sc_hd__fill_1
XFILLER_59_632 VGND VGND VPWR VPWR sky130_fd_sc_hd__decap_3
X_7219_ _7349_/CLK _7219_/D _6499_/Y VGND VGND VPWR VPWR _7219_/Q sky130_fd_sc_hd__dfrtp_2
XFILLER_86_451 VGND VGND VPWR VPWR sky130_fd_sc_hd__decap_3
XFILLER_100_261 VGND VGND VPWR VPWR sky130_fd_sc_hd__fill_1
XFILLER_58_153 VGND VGND VPWR VPWR sky130_fd_sc_hd__decap_3
XFILLER_58_175 VGND VGND VPWR VPWR sky130_fd_sc_hd__decap_3
XFILLER_58_197 VGND VGND VPWR VPWR sky130_fd_sc_hd__decap_3
XFILLER_73_134 VGND VGND VPWR VPWR sky130_fd_sc_hd__decap_3
XFILLER_27_551 VGND VGND VPWR VPWR sky130_fd_sc_hd__decap_3
XFILLER_61_307 VGND VGND VPWR VPWR sky130_fd_sc_hd__decap_3
XTAP_TAPCELL_ROW_57_888 VGND VPWR sky130_fd_sc_hd__tapvpwrvgnd_1
XTAP_TAPCELL_ROW_29_568 VGND VPWR sky130_fd_sc_hd__tapvpwrvgnd_1
XFILLER_27_573 VGND VGND VPWR VPWR sky130_fd_sc_hd__decap_3
XFILLER_42_510 VGND VGND VPWR VPWR sky130_fd_sc_hd__decap_3
XFILLER_73_178 VGND VGND VPWR VPWR sky130_fd_sc_hd__decap_3
XTAP_TAPCELL_ROW_107_1463 VGND VPWR sky130_fd_sc_hd__tapvpwrvgnd_1
XFILLER_14_245 VGND VGND VPWR VPWR sky130_fd_sc_hd__decap_3
XFILLER_42_565 VGND VGND VPWR VPWR sky130_fd_sc_hd__fill_2
XFILLER_14_289 VGND VGND VPWR VPWR sky130_fd_sc_hd__decap_3
XTAP_TAPCELL_ROW_40_700 VGND VPWR sky130_fd_sc_hd__tapvpwrvgnd_1
XFILLER_9_28 VGND VGND VPWR VPWR sky130_fd_sc_hd__fill_1
XFILLER_80_54 VGND VGND VPWR VPWR sky130_fd_sc_hd__decap_3
Xfanout60 _6611_/A VGND VGND VPWR VPWR _6618_/A sky130_fd_sc_hd__buf_2
Xfanout71 _6397_/A VGND VGND VPWR VPWR _6558_/A sky130_fd_sc_hd__buf_1
XFILLER_10_451 VGND VGND VPWR VPWR sky130_fd_sc_hd__decap_3
XFILLER_6_400 VGND VGND VPWR VPWR sky130_fd_sc_hd__fill_2
XFILLER_6_411 VGND VGND VPWR VPWR sky130_fd_sc_hd__decap_3
XFILLER_13_92 VGND VGND VPWR VPWR sky130_fd_sc_hd__decap_3
XFILLER_69_418 VGND VGND VPWR VPWR sky130_fd_sc_hd__decap_3
XFILLER_96_259 VGND VGND VPWR VPWR sky130_fd_sc_hd__fill_2
XFILLER_49_142 VGND VGND VPWR VPWR sky130_fd_sc_hd__fill_1
XFILLER_49_175 VGND VGND VPWR VPWR sky130_fd_sc_hd__decap_3
XFILLER_37_337 VGND VGND VPWR VPWR sky130_fd_sc_hd__decap_3
XFILLER_65_635 VGND VGND VPWR VPWR sky130_fd_sc_hd__decap_3
XFILLER_92_421 VGND VGND VPWR VPWR sky130_fd_sc_hd__fill_2
XFILLER_92_432 VGND VGND VPWR VPWR sky130_fd_sc_hd__decap_3
XFILLER_64_145 VGND VGND VPWR VPWR sky130_fd_sc_hd__decap_3
XFILLER_80_616 VGND VGND VPWR VPWR sky130_fd_sc_hd__decap_3
XFILLER_92_465 VGND VGND VPWR VPWR sky130_fd_sc_hd__decap_3
XFILLER_18_584 VGND VGND VPWR VPWR sky130_fd_sc_hd__decap_3
XFILLER_18_595 VGND VGND VPWR VPWR sky130_fd_sc_hd__decap_3
XFILLER_33_521 VGND VGND VPWR VPWR sky130_fd_sc_hd__decap_3
XFILLER_45_370 VGND VGND VPWR VPWR sky130_fd_sc_hd__decap_3
XFILLER_64_178 VGND VGND VPWR VPWR sky130_fd_sc_hd__decap_3
XFILLER_92_487 VGND VGND VPWR VPWR sky130_fd_sc_hd__decap_3
X_4920_ _4920_/A _4920_/B VGND VGND VPWR VPWR _4920_/Y sky130_fd_sc_hd__xnor2_2
XFILLER_33_554 VGND VGND VPWR VPWR sky130_fd_sc_hd__decap_3
X_4851_ _4633_/A _4142_/X _4849_/Y _4850_/Y _4969_/B VGND VGND VPWR VPWR _4855_/B
+ sky130_fd_sc_hd__o311a_2
XFILLER_33_598 VGND VGND VPWR VPWR sky130_fd_sc_hd__decap_3
X_3802_ _3733_/X _3794_/X _3796_/X _3746_/X _3801_/X VGND VGND VPWR VPWR _3802_/X
+ sky130_fd_sc_hd__a221o_2
XTAP_TAPCELL_ROW_82_1179 VGND VPWR sky130_fd_sc_hd__tapvpwrvgnd_1
XFILLER_20_215 VGND VGND VPWR VPWR sky130_fd_sc_hd__fill_2
XFILLER_60_395 VGND VGND VPWR VPWR sky130_fd_sc_hd__decap_3
X_4782_ _4413_/A _4444_/X _4780_/Y _4969_/B VGND VGND VPWR VPWR _4782_/Y sky130_fd_sc_hd__o31ai_2
X_6521_ _6652_/A VGND VGND VPWR VPWR _6521_/Y sky130_fd_sc_hd__inv_2
X_3733_ _3746_/A _3741_/B _3733_/C VGND VGND VPWR VPWR _3733_/X sky130_fd_sc_hd__and3_2
X_6452_ _6645_/A VGND VGND VPWR VPWR _6452_/Y sky130_fd_sc_hd__inv_2
XFILLER_9_271 VGND VGND VPWR VPWR sky130_fd_sc_hd__decap_3
Xclkload30 _7392_/CLK VGND VGND VPWR VPWR clkload30/Y sky130_fd_sc_hd__clkinv_2
X_6383_ _6612_/A VGND VGND VPWR VPWR _6383_/Y sky130_fd_sc_hd__inv_2
X_3595_ _4292_/A _3594_/B _3594_/Y _5020_/A VGND VGND VPWR VPWR _3614_/A sky130_fd_sc_hd__a211o_2
XFILLER_102_526 VGND VGND VPWR VPWR sky130_fd_sc_hd__decap_3
XFILLER_102_548 VGND VGND VPWR VPWR sky130_fd_sc_hd__decap_3
X_7004_ _7373_/CLK _7004_/D _6284_/Y VGND VGND VPWR VPWR _7004_/Q sky130_fd_sc_hd__dfrtp_2
X_5196_ _5196_/A _5207_/B VGND VGND VPWR VPWR _7230_/D sky130_fd_sc_hd__and2_2
X_4216_ _7068_/Q _4265_/B _4205_/A VGND VGND VPWR VPWR _4371_/B sky130_fd_sc_hd__o21a_2
XFILLER_56_624 VGND VGND VPWR VPWR sky130_fd_sc_hd__decap_3
X_4147_ _7266_/Q _4190_/A2 _3956_/S _7330_/Q _4146_/X VGND VGND VPWR VPWR _4147_/X
+ sky130_fd_sc_hd__a221o_2
XFILLER_28_348 VGND VGND VPWR VPWR sky130_fd_sc_hd__decap_3
XFILLER_55_101 VGND VGND VPWR VPWR sky130_fd_sc_hd__decap_3
XFILLER_83_421 VGND VGND VPWR VPWR sky130_fd_sc_hd__decap_3
XFILLER_95_281 VGND VGND VPWR VPWR sky130_fd_sc_hd__decap_3
XFILLER_43_307 VGND VGND VPWR VPWR sky130_fd_sc_hd__decap_3
XFILLER_55_156 VGND VGND VPWR VPWR sky130_fd_sc_hd__decap_3
X_4078_ _7025_/Q _4437_/A2 _4394_/B _7371_/Q VGND VGND VPWR VPWR _4078_/X sky130_fd_sc_hd__a22o_2
XFILLER_24_510 VGND VGND VPWR VPWR sky130_fd_sc_hd__decap_3
XFILLER_55_178 VGND VGND VPWR VPWR sky130_fd_sc_hd__decap_3
XFILLER_71_638 VGND VGND VPWR VPWR sky130_fd_sc_hd__decap_3
XFILLER_24_543 VGND VGND VPWR VPWR sky130_fd_sc_hd__decap_3
XFILLER_36_392 VGND VGND VPWR VPWR sky130_fd_sc_hd__fill_2
XFILLER_51_340 VGND VGND VPWR VPWR sky130_fd_sc_hd__decap_3
XFILLER_70_159 VGND VGND VPWR VPWR sky130_fd_sc_hd__decap_3
XTAP_TAPCELL_ROW_54_858 VGND VPWR sky130_fd_sc_hd__tapvpwrvgnd_1
XTAP_TAPCELL_ROW_26_538 VGND VPWR sky130_fd_sc_hd__tapvpwrvgnd_1
XFILLER_24_565 VGND VGND VPWR VPWR sky130_fd_sc_hd__decap_3
XFILLER_11_215 VGND VGND VPWR VPWR sky130_fd_sc_hd__fill_2
XFILLER_11_248 VGND VGND VPWR VPWR sky130_fd_sc_hd__decap_3
XFILLER_24_598 VGND VGND VPWR VPWR sky130_fd_sc_hd__decap_3
XFILLER_7_219 VGND VGND VPWR VPWR sky130_fd_sc_hd__decap_3
Xclkload2 clkload2/A VGND VGND VPWR VPWR clkload2/X sky130_fd_sc_hd__clkbuf_16
X_6719_ _6974_/CLK _6719_/D VGND VGND VPWR VPWR _6719_/Q sky130_fd_sc_hd__dfxtp_2
XFILLER_50_68 VGND VGND VPWR VPWR sky130_fd_sc_hd__decap_3
XFILLER_3_414 VGND VGND VPWR VPWR sky130_fd_sc_hd__decap_3
XFILLER_105_353 VGND VGND VPWR VPWR sky130_fd_sc_hd__decap_3
XFILLER_59_11 VGND VGND VPWR VPWR sky130_fd_sc_hd__fill_1
XFILLER_59_55 VGND VGND VPWR VPWR sky130_fd_sc_hd__fill_1
XFILLER_47_613 VGND VGND VPWR VPWR sky130_fd_sc_hd__decap_3
XFILLER_59_473 VGND VGND VPWR VPWR sky130_fd_sc_hd__fill_1
XFILLER_93_207 VGND VGND VPWR VPWR sky130_fd_sc_hd__decap_3
XFILLER_101_570 VGND VGND VPWR VPWR sky130_fd_sc_hd__decap_3
XFILLER_19_337 VGND VGND VPWR VPWR sky130_fd_sc_hd__decap_3
XFILLER_47_635 VGND VGND VPWR VPWR sky130_fd_sc_hd__decap_3
XFILLER_74_421 VGND VGND VPWR VPWR sky130_fd_sc_hd__decap_3
XFILLER_46_156 VGND VGND VPWR VPWR sky130_fd_sc_hd__decap_3
XFILLER_34_318 VGND VGND VPWR VPWR sky130_fd_sc_hd__fill_1
XFILLER_62_627 VGND VGND VPWR VPWR sky130_fd_sc_hd__decap_3
XFILLER_91_31 VGND VGND VPWR VPWR sky130_fd_sc_hd__fill_2
XFILLER_15_576 VGND VGND VPWR VPWR sky130_fd_sc_hd__decap_3
XFILLER_30_524 VGND VGND VPWR VPWR sky130_fd_sc_hd__decap_3
XFILLER_42_384 VGND VGND VPWR VPWR sky130_fd_sc_hd__fill_1
XFILLER_24_91 VGND VGND VPWR VPWR sky130_fd_sc_hd__fill_2
XFILLER_30_579 VGND VGND VPWR VPWR sky130_fd_sc_hd__decap_3
Xhold709 _6749_/Q VGND VGND VPWR VPWR _6749_/D sky130_fd_sc_hd__dlygate4sd3_1
XFILLER_108_180 VGND VGND VPWR VPWR sky130_fd_sc_hd__decap_3
X_3380_ _3528_/A _5118_/D VGND VGND VPWR VPWR _3380_/Y sky130_fd_sc_hd__nor2_2
XFILLER_69_215 VGND VGND VPWR VPWR sky130_fd_sc_hd__decap_3
XFILLER_97_535 VGND VGND VPWR VPWR sky130_fd_sc_hd__decap_3
XFILLER_2_480 VGND VGND VPWR VPWR sky130_fd_sc_hd__fill_2
X_5050_ _5086_/A _5101_/B _5100_/B _4366_/X VGND VGND VPWR VPWR _5050_/X sky130_fd_sc_hd__a31o_2
XFILLER_27_3 VGND VGND VPWR VPWR sky130_fd_sc_hd__fill_2
XFILLER_97_579 VGND VGND VPWR VPWR sky130_fd_sc_hd__fill_1
XFILLER_38_624 VGND VGND VPWR VPWR sky130_fd_sc_hd__decap_3
XFILLER_53_605 VGND VGND VPWR VPWR sky130_fd_sc_hd__decap_3
XFILLER_92_240 VGND VGND VPWR VPWR sky130_fd_sc_hd__fill_2
XFILLER_37_189 VGND VGND VPWR VPWR sky130_fd_sc_hd__fill_1
XFILLER_53_638 VGND VGND VPWR VPWR sky130_fd_sc_hd__decap_3
XFILLER_65_487 VGND VGND VPWR VPWR sky130_fd_sc_hd__decap_3
XFILLER_92_262 VGND VGND VPWR VPWR sky130_fd_sc_hd__decap_3
X_4903_ _4903_/A _4903_/B _4903_/C VGND VGND VPWR VPWR _4903_/X sky130_fd_sc_hd__and3_2
XFILLER_21_502 VGND VGND VPWR VPWR sky130_fd_sc_hd__fill_2
XFILLER_33_351 VGND VGND VPWR VPWR sky130_fd_sc_hd__decap_3
XTAP_TAPCELL_ROW_51_817 VGND VPWR sky130_fd_sc_hd__tapvpwrvgnd_1
XFILLER_21_546 VGND VGND VPWR VPWR sky130_fd_sc_hd__fill_1
X_4834_ _4834_/A _4834_/B VGND VGND VPWR VPWR _4834_/Y sky130_fd_sc_hd__nor2_2
XFILLER_21_568 VGND VGND VPWR VPWR sky130_fd_sc_hd__fill_1
X_4765_ _4788_/A _4765_/B VGND VGND VPWR VPWR _4766_/A sky130_fd_sc_hd__and2_2
X_6504_ _6592_/A VGND VGND VPWR VPWR _6504_/Y sky130_fd_sc_hd__inv_2
XFILLER_107_629 VGND VGND VPWR VPWR sky130_fd_sc_hd__decap_3
X_4696_ _5118_/C _4696_/B VGND VGND VPWR VPWR _5670_/B sky130_fd_sc_hd__nor2_2
XTAP_TAPCELL_ROW_95_1326 VGND VPWR sky130_fd_sc_hd__tapvpwrvgnd_1
XTAP_TAPCELL_ROW_31_596 VGND VPWR sky130_fd_sc_hd__tapvpwrvgnd_1
XFILLER_106_106 VGND VGND VPWR VPWR sky130_fd_sc_hd__fill_1
XFILLER_106_128 VGND VGND VPWR VPWR sky130_fd_sc_hd__decap_3
X_6435_ _6628_/A VGND VGND VPWR VPWR _6435_/Y sky130_fd_sc_hd__inv_2
X_6366_ _6554_/A VGND VGND VPWR VPWR _6366_/Y sky130_fd_sc_hd__inv_2
X_3578_ _7284_/Q _5132_/S _3417_/X _7092_/Q VGND VGND VPWR VPWR _3583_/A sky130_fd_sc_hd__a22o_2
XFILLER_102_312 VGND VGND VPWR VPWR sky130_fd_sc_hd__decap_3
XFILLER_88_524 VGND VGND VPWR VPWR sky130_fd_sc_hd__decap_3
X_5317_ _5317_/A0 _4899_/X _5333_/S VGND VGND VPWR VPWR _7172_/D sky130_fd_sc_hd__mux2_2
X_6297_ _6612_/A VGND VGND VPWR VPWR _6297_/Y sky130_fd_sc_hd__inv_2
XFILLER_29_602 VGND VGND VPWR VPWR sky130_fd_sc_hd__decap_3
XTAP_TAPCELL_ROW_59_917 VGND VPWR sky130_fd_sc_hd__tapvpwrvgnd_1
XFILLER_28_123 VGND VGND VPWR VPWR sky130_fd_sc_hd__fill_2
XFILLER_29_635 VGND VGND VPWR VPWR sky130_fd_sc_hd__decap_3
X_5179_ _5179_/A _5186_/B VGND VGND VPWR VPWR _7238_/D sky130_fd_sc_hd__and2_2
XFILLER_28_156 VGND VGND VPWR VPWR sky130_fd_sc_hd__decap_3
XFILLER_56_443 VGND VGND VPWR VPWR sky130_fd_sc_hd__decap_3
XFILLER_56_454 VGND VGND VPWR VPWR sky130_fd_sc_hd__decap_3
XFILLER_56_465 VGND VGND VPWR VPWR sky130_fd_sc_hd__decap_3
XFILLER_83_240 VGND VGND VPWR VPWR sky130_fd_sc_hd__decap_3
XFILLER_83_251 VGND VGND VPWR VPWR sky130_fd_sc_hd__decap_3
XTAP_TAPCELL_ROW_3_266 VGND VPWR sky130_fd_sc_hd__tapvpwrvgnd_1
XFILLER_16_318 VGND VGND VPWR VPWR sky130_fd_sc_hd__decap_3
XFILLER_16_329 VGND VGND VPWR VPWR sky130_fd_sc_hd__decap_3
XFILLER_28_167 VGND VGND VPWR VPWR sky130_fd_sc_hd__decap_3
XFILLER_44_616 VGND VGND VPWR VPWR sky130_fd_sc_hd__decap_3
XFILLER_71_413 VGND VGND VPWR VPWR sky130_fd_sc_hd__decap_3
XFILLER_83_284 VGND VGND VPWR VPWR sky130_fd_sc_hd__decap_3
XTAP_TAPCELL_ROW_39_685 VGND VPWR sky130_fd_sc_hd__tapvpwrvgnd_1
XTAP_TAPCELL_ROW_104_1433 VGND VPWR sky130_fd_sc_hd__tapvpwrvgnd_1
XFILLER_12_502 VGND VGND VPWR VPWR sky130_fd_sc_hd__decap_3
XFILLER_24_351 VGND VGND VPWR VPWR sky130_fd_sc_hd__decap_3
XFILLER_71_479 VGND VGND VPWR VPWR sky130_fd_sc_hd__decap_3
XFILLER_51_181 VGND VGND VPWR VPWR sky130_fd_sc_hd__decap_3
XFILLER_61_34 VGND VGND VPWR VPWR sky130_fd_sc_hd__decap_3
XFILLER_12_579 VGND VGND VPWR VPWR sky130_fd_sc_hd__decap_3
XFILLER_8_528 VGND VGND VPWR VPWR sky130_fd_sc_hd__decap_3
XFILLER_8_539 VGND VGND VPWR VPWR sky130_fd_sc_hd__decap_3
XFILLER_6_29 VGND VGND VPWR VPWR sky130_fd_sc_hd__fill_2
XFILLER_3_222 VGND VGND VPWR VPWR sky130_fd_sc_hd__fill_2
XFILLER_3_277 VGND VGND VPWR VPWR sky130_fd_sc_hd__decap_3
XFILLER_105_194 VGND VGND VPWR VPWR sky130_fd_sc_hd__decap_3
XFILLER_10_93 VGND VGND VPWR VPWR sky130_fd_sc_hd__decap_3
XFILLER_79_535 VGND VGND VPWR VPWR sky130_fd_sc_hd__fill_1
XFILLER_94_505 VGND VGND VPWR VPWR sky130_fd_sc_hd__fill_2
XFILLER_66_229 VGND VGND VPWR VPWR sky130_fd_sc_hd__decap_3
XFILLER_19_134 VGND VGND VPWR VPWR sky130_fd_sc_hd__decap_3
XFILLER_47_465 VGND VGND VPWR VPWR sky130_fd_sc_hd__decap_3
XFILLER_19_167 VGND VGND VPWR VPWR sky130_fd_sc_hd__fill_1
XFILLER_35_638 VGND VGND VPWR VPWR sky130_fd_sc_hd__decap_3
XFILLER_47_498 VGND VGND VPWR VPWR sky130_fd_sc_hd__decap_3
XFILLER_62_402 VGND VGND VPWR VPWR sky130_fd_sc_hd__fill_1
XFILLER_62_457 VGND VGND VPWR VPWR sky130_fd_sc_hd__fill_1
XFILLER_15_340 VGND VGND VPWR VPWR sky130_fd_sc_hd__decap_3
XFILLER_34_159 VGND VGND VPWR VPWR sky130_fd_sc_hd__decap_3
XFILLER_50_608 VGND VGND VPWR VPWR sky130_fd_sc_hd__decap_3
XFILLER_30_365 VGND VGND VPWR VPWR sky130_fd_sc_hd__decap_3
X_4550_ _7305_/Q _4563_/B VGND VGND VPWR VPWR _7305_/D sky130_fd_sc_hd__and2_2
XFILLER_7_561 VGND VGND VPWR VPWR sky130_fd_sc_hd__decap_3
XFILLER_7_594 VGND VGND VPWR VPWR sky130_fd_sc_hd__decap_3
X_3501_ _5144_/A _5144_/B _3500_/Y VGND VGND VPWR VPWR _3501_/X sky130_fd_sc_hd__a21o_2
X_3363_ _3561_/A _5670_/A _3353_/B VGND VGND VPWR VPWR _5294_/B sky130_fd_sc_hd__or3b_4
X_5102_ _5072_/A _4343_/X _5100_/Y _3618_/X _5101_/Y VGND VGND VPWR VPWR _5102_/X
+ sky130_fd_sc_hd__a221o_2
XTAP_TAPCELL_ROW_90_1267 VGND VPWR sky130_fd_sc_hd__tapvpwrvgnd_1
XFILLER_97_343 VGND VGND VPWR VPWR sky130_fd_sc_hd__decap_3
XFILLER_97_332 VGND VGND VPWR VPWR sky130_fd_sc_hd__decap_3
XFILLER_85_505 VGND VGND VPWR VPWR sky130_fd_sc_hd__decap_3
Xhold1206 _7174_/Q VGND VGND VPWR VPWR _5312_/A0 sky130_fd_sc_hd__dlygate4sd3_1
XFILLER_85_538 VGND VGND VPWR VPWR sky130_fd_sc_hd__decap_3
Xhold1217 _7215_/Q VGND VGND VPWR VPWR _5227_/A1 sky130_fd_sc_hd__dlygate4sd3_1
X_5033_ _5072_/A _4629_/Y _5032_/A _5033_/B2 VGND VGND VPWR VPWR _5033_/X sky130_fd_sc_hd__a22o_2
XFILLER_26_605 VGND VGND VPWR VPWR sky130_fd_sc_hd__decap_3
XFILLER_26_638 VGND VGND VPWR VPWR sky130_fd_sc_hd__decap_3
XFILLER_65_284 VGND VGND VPWR VPWR sky130_fd_sc_hd__decap_3
XTAP_TAPCELL_ROW_0_236 VGND VPWR sky130_fd_sc_hd__tapvpwrvgnd_1
XTAP_TAPCELL_ROW_0_225 VGND VPWR sky130_fd_sc_hd__tapvpwrvgnd_1
XFILLER_53_446 VGND VGND VPWR VPWR sky130_fd_sc_hd__fill_2
XFILLER_53_457 VGND VGND VPWR VPWR sky130_fd_sc_hd__decap_3
XFILLER_80_221 VGND VGND VPWR VPWR sky130_fd_sc_hd__decap_3
X_6984_ _7383_/CLK _6984_/D _6264_/Y VGND VGND VPWR VPWR _6984_/Q sky130_fd_sc_hd__dfrtp_2
XTAP_TAPCELL_ROW_36_644 VGND VPWR sky130_fd_sc_hd__tapvpwrvgnd_1
XFILLER_25_159 VGND VGND VPWR VPWR sky130_fd_sc_hd__decap_3
XTAP_TAPCELL_ROW_64_975 VGND VPWR sky130_fd_sc_hd__tapvpwrvgnd_1
XFILLER_21_332 VGND VGND VPWR VPWR sky130_fd_sc_hd__decap_3
XFILLER_21_354 VGND VGND VPWR VPWR sky130_fd_sc_hd__decap_3
XFILLER_33_192 VGND VGND VPWR VPWR sky130_fd_sc_hd__decap_3
X_4817_ _4810_/X _4811_/X _4815_/X _4816_/X VGND VGND VPWR VPWR _5663_/B sky130_fd_sc_hd__a211o_2
XFILLER_21_387 VGND VGND VPWR VPWR sky130_fd_sc_hd__decap_3
XFILLER_31_37 VGND VGND VPWR VPWR sky130_fd_sc_hd__decap_3
X_4748_ _3683_/Y _5664_/B _4791_/C1 VGND VGND VPWR VPWR _4751_/A sky130_fd_sc_hd__a21o_2
XFILLER_107_437 VGND VGND VPWR VPWR sky130_fd_sc_hd__decap_3
X_4679_ _6990_/Q _5014_/B VGND VGND VPWR VPWR _5015_/B sky130_fd_sc_hd__nand2_2
X_6418_ _6645_/A VGND VGND VPWR VPWR _6418_/Y sky130_fd_sc_hd__inv_2
XPHY_EDGE_ROW_1_Right_1 VGND VGND VPWR VPWR sky130_fd_sc_hd__decap_3
X_7398_ _7398_/CLK _7398_/D _6678_/Y VGND VGND VPWR VPWR _7398_/Q sky130_fd_sc_hd__dfrtp_2
XTAP_TAPCELL_ROW_8_325 VGND VPWR sky130_fd_sc_hd__tapvpwrvgnd_1
XFILLER_0_225 VGND VGND VPWR VPWR sky130_fd_sc_hd__decap_3
XFILLER_103_632 VGND VGND VPWR VPWR sky130_fd_sc_hd__decap_3
X_6349_ _6668_/A VGND VGND VPWR VPWR _6349_/Y sky130_fd_sc_hd__inv_2
XFILLER_0_269 VGND VGND VPWR VPWR sky130_fd_sc_hd__decap_3
XFILLER_102_153 VGND VGND VPWR VPWR sky130_fd_sc_hd__decap_3
XFILLER_76_516 VGND VGND VPWR VPWR sky130_fd_sc_hd__decap_3
XFILLER_88_365 VGND VGND VPWR VPWR sky130_fd_sc_hd__decap_3
XFILLER_48_218 VGND VGND VPWR VPWR sky130_fd_sc_hd__decap_3
XFILLER_56_23 VGND VGND VPWR VPWR sky130_fd_sc_hd__decap_3
XFILLER_88_387 VGND VGND VPWR VPWR sky130_fd_sc_hd__decap_3
XFILLER_56_56 VGND VGND VPWR VPWR sky130_fd_sc_hd__decap_3
XFILLER_91_508 VGND VGND VPWR VPWR sky130_fd_sc_hd__decap_3
XFILLER_17_638 VGND VGND VPWR VPWR sky130_fd_sc_hd__decap_3
XFILLER_44_402 VGND VGND VPWR VPWR sky130_fd_sc_hd__decap_3
XFILLER_56_78 VGND VGND VPWR VPWR sky130_fd_sc_hd__decap_3
XFILLER_32_619 VGND VGND VPWR VPWR sky130_fd_sc_hd__decap_3
XFILLER_72_11 VGND VGND VPWR VPWR sky130_fd_sc_hd__fill_1
XFILLER_40_630 VGND VGND VPWR VPWR sky130_fd_sc_hd__decap_3
XFILLER_52_490 VGND VGND VPWR VPWR sky130_fd_sc_hd__decap_3
XFILLER_12_354 VGND VGND VPWR VPWR sky130_fd_sc_hd__fill_1
XFILLER_12_387 VGND VGND VPWR VPWR sky130_fd_sc_hd__decap_3
XFILLER_8_336 VGND VGND VPWR VPWR sky130_fd_sc_hd__decap_3
XFILLER_4_531 VGND VGND VPWR VPWR sky130_fd_sc_hd__fill_1
XFILLER_4_575 VGND VGND VPWR VPWR sky130_fd_sc_hd__decap_3
XFILLER_79_343 VGND VGND VPWR VPWR sky130_fd_sc_hd__decap_3
XFILLER_67_516 VGND VGND VPWR VPWR sky130_fd_sc_hd__decap_3
XFILLER_79_365 VGND VGND VPWR VPWR sky130_fd_sc_hd__decap_3
XFILLER_94_302 VGND VGND VPWR VPWR sky130_fd_sc_hd__decap_3
XFILLER_79_387 VGND VGND VPWR VPWR sky130_fd_sc_hd__decap_3
XFILLER_94_324 VGND VGND VPWR VPWR sky130_fd_sc_hd__decap_3
XFILLER_11_6 VGND VGND VPWR VPWR sky130_fd_sc_hd__fill_1
XFILLER_47_262 VGND VGND VPWR VPWR sky130_fd_sc_hd__decap_3
XFILLER_75_571 VGND VGND VPWR VPWR sky130_fd_sc_hd__decap_3
XFILLER_35_424 VGND VGND VPWR VPWR sky130_fd_sc_hd__decap_3
XFILLER_35_435 VGND VGND VPWR VPWR sky130_fd_sc_hd__decap_3
XFILLER_47_284 VGND VGND VPWR VPWR sky130_fd_sc_hd__decap_3
XFILLER_90_541 VGND VGND VPWR VPWR sky130_fd_sc_hd__decap_3
XFILLER_50_416 VGND VGND VPWR VPWR sky130_fd_sc_hd__fill_1
X_3981_ _7350_/Q _4522_/A0 _3996_/S VGND VGND VPWR VPWR _3981_/X sky130_fd_sc_hd__mux2_2
XTAP_TAPCELL_ROW_61_934 VGND VPWR sky130_fd_sc_hd__tapvpwrvgnd_1
XTAP_TAPCELL_ROW_33_614 VGND VPWR sky130_fd_sc_hd__tapvpwrvgnd_1
XFILLER_31_641 VGND VGND VPWR VPWR sky130_fd_sc_hd__decap_3
Xclkbuf_leaf_42_clk clkbuf_leaf_2_clk/A VGND VGND VPWR VPWR _7382_/CLK sky130_fd_sc_hd__clkbuf_16
X_5651_ _5660_/C VGND VGND VPWR VPWR _5651_/Y sky130_fd_sc_hd__inv_2
XTAP_TAPCELL_ROW_13_382 VGND VPWR sky130_fd_sc_hd__tapvpwrvgnd_1
X_7321_ _7356_/CLK _7321_/D _6601_/Y VGND VGND VPWR VPWR _7321_/Q sky130_fd_sc_hd__dfrtp_2
XFILLER_7_380 VGND VGND VPWR VPWR sky130_fd_sc_hd__decap_3
X_7252_ _7349_/CLK _7252_/D _6532_/Y VGND VGND VPWR VPWR _7252_/Q sky130_fd_sc_hd__dfrtp_2
X_4464_ _3541_/X _3610_/B _4463_/X VGND VGND VPWR VPWR _5655_/C sky130_fd_sc_hd__o21ai_2
X_7183_ _7383_/CLK _7183_/D _6463_/Y VGND VGND VPWR VPWR _7183_/Q sky130_fd_sc_hd__dfrtp_2
X_4395_ _4396_/A _4444_/B VGND VGND VPWR VPWR _4397_/A sky130_fd_sc_hd__and2_2
X_3415_ _3449_/B _3449_/C _3417_/C VGND VGND VPWR VPWR _5132_/S sky130_fd_sc_hd__and3_4
X_3346_ _3346_/A VGND VGND VPWR VPWR _3509_/B sky130_fd_sc_hd__inv_2
XFILLER_97_140 VGND VGND VPWR VPWR sky130_fd_sc_hd__decap_3
XFILLER_85_324 VGND VGND VPWR VPWR sky130_fd_sc_hd__decap_3
Xhold1003 _7257_/Q VGND VGND VPWR VPWR _5080_/A0 sky130_fd_sc_hd__dlygate4sd3_1
Xhold1014 _7260_/Q VGND VGND VPWR VPWR _5028_/A0 sky130_fd_sc_hd__dlygate4sd3_1
XFILLER_97_184 VGND VGND VPWR VPWR sky130_fd_sc_hd__decap_3
Xhold1025 _7274_/Q VGND VGND VPWR VPWR _4793_/A0 sky130_fd_sc_hd__dlygate4sd3_1
Xhold1036 _7190_/Q VGND VGND VPWR VPWR _5280_/A0 sky130_fd_sc_hd__dlygate4sd3_1
Xhold1047 _7204_/Q VGND VGND VPWR VPWR _5251_/A0 sky130_fd_sc_hd__dlygate4sd3_1
Xhold1058 _3981_/X VGND VGND VPWR VPWR _7350_/D sky130_fd_sc_hd__dlygate4sd3_1
X_5016_ _5032_/A _5031_/B _4629_/Y VGND VGND VPWR VPWR _5017_/B sky130_fd_sc_hd__a21oi_2
XFILLER_38_251 VGND VGND VPWR VPWR sky130_fd_sc_hd__fill_1
XFILLER_38_262 VGND VGND VPWR VPWR sky130_fd_sc_hd__decap_3
XFILLER_66_582 VGND VGND VPWR VPWR sky130_fd_sc_hd__fill_2
XFILLER_73_519 VGND VGND VPWR VPWR sky130_fd_sc_hd__fill_2
Xhold1069 _7329_/Q VGND VGND VPWR VPWR _4501_/A0 sky130_fd_sc_hd__dlygate4sd3_1
XFILLER_14_619 VGND VGND VPWR VPWR sky130_fd_sc_hd__decap_3
XFILLER_53_243 VGND VGND VPWR VPWR sky130_fd_sc_hd__decap_3
X_6967_ clkload6/A _6967_/D VGND VGND VPWR VPWR _6967_/Q sky130_fd_sc_hd__dfxtp_2
XFILLER_13_129 VGND VGND VPWR VPWR sky130_fd_sc_hd__decap_3
XFILLER_34_490 VGND VGND VPWR VPWR sky130_fd_sc_hd__decap_3
Xclkbuf_leaf_33_clk clkload0/A VGND VGND VPWR VPWR _7356_/CLK sky130_fd_sc_hd__clkbuf_16
X_6898_ clkload7/A _6898_/D VGND VGND VPWR VPWR _6898_/Q sky130_fd_sc_hd__dfxtp_2
XFILLER_21_151 VGND VGND VPWR VPWR sky130_fd_sc_hd__decap_3
XFILLER_21_195 VGND VGND VPWR VPWR sky130_fd_sc_hd__decap_3
XFILLER_107_40 VGND VGND VPWR VPWR sky130_fd_sc_hd__decap_3
XFILLER_1_523 VGND VGND VPWR VPWR sky130_fd_sc_hd__decap_3
Xhold870 _7082_/Q VGND VGND VPWR VPWR _7082_/D sky130_fd_sc_hd__dlygate4sd3_1
Xhold881 _7064_/Q VGND VGND VPWR VPWR _7064_/D sky130_fd_sc_hd__dlygate4sd3_1
XFILLER_107_84 VGND VGND VPWR VPWR sky130_fd_sc_hd__decap_3
XFILLER_1_556 VGND VGND VPWR VPWR sky130_fd_sc_hd__decap_3
XFILLER_1_567 VGND VGND VPWR VPWR sky130_fd_sc_hd__decap_3
XFILLER_49_505 VGND VGND VPWR VPWR sky130_fd_sc_hd__fill_2
Xhold892 _7099_/Q VGND VGND VPWR VPWR _7099_/D sky130_fd_sc_hd__dlygate4sd3_1
XFILLER_67_66 VGND VGND VPWR VPWR sky130_fd_sc_hd__decap_3
XFILLER_76_302 VGND VGND VPWR VPWR sky130_fd_sc_hd__decap_3
XFILLER_88_184 VGND VGND VPWR VPWR sky130_fd_sc_hd__fill_1
XFILLER_76_346 VGND VGND VPWR VPWR sky130_fd_sc_hd__decap_3
XFILLER_76_368 VGND VGND VPWR VPWR sky130_fd_sc_hd__decap_3
XFILLER_17_402 VGND VGND VPWR VPWR sky130_fd_sc_hd__decap_3
XFILLER_29_240 VGND VGND VPWR VPWR sky130_fd_sc_hd__decap_3
XFILLER_57_571 VGND VGND VPWR VPWR sky130_fd_sc_hd__decap_3
XTAP_TAPCELL_ROW_67_1000 VGND VPWR sky130_fd_sc_hd__tapvpwrvgnd_1
XFILLER_17_446 VGND VGND VPWR VPWR sky130_fd_sc_hd__fill_2
XFILLER_17_457 VGND VGND VPWR VPWR sky130_fd_sc_hd__decap_3
XFILLER_44_265 VGND VGND VPWR VPWR sky130_fd_sc_hd__decap_3
XFILLER_32_416 VGND VGND VPWR VPWR sky130_fd_sc_hd__decap_3
XFILLER_13_641 VGND VGND VPWR VPWR sky130_fd_sc_hd__decap_3
Xclkbuf_leaf_24_clk clkload2/A VGND VGND VPWR VPWR _7373_/CLK sky130_fd_sc_hd__clkbuf_16
XFILLER_12_162 VGND VGND VPWR VPWR sky130_fd_sc_hd__decap_3
XFILLER_9_623 VGND VGND VPWR VPWR sky130_fd_sc_hd__decap_3
XFILLER_9_612 VGND VGND VPWR VPWR sky130_fd_sc_hd__decap_3
XFILLER_8_144 VGND VGND VPWR VPWR sky130_fd_sc_hd__decap_3
XFILLER_32_80 VGND VGND VPWR VPWR sky130_fd_sc_hd__decap_3
XTAP_TAPCELL_ROW_10_352 VGND VPWR sky130_fd_sc_hd__tapvpwrvgnd_1
XFILLER_99_449 VGND VGND VPWR VPWR sky130_fd_sc_hd__decap_3
XFILLER_79_140 VGND VGND VPWR VPWR sky130_fd_sc_hd__decap_3
X_4180_ _7232_/Q _4353_/A2 _4534_/S _7045_/Q VGND VGND VPWR VPWR _4180_/X sky130_fd_sc_hd__a22o_2
XFILLER_79_184 VGND VGND VPWR VPWR sky130_fd_sc_hd__fill_2
XFILLER_95_633 VGND VGND VPWR VPWR sky130_fd_sc_hd__decap_3
XFILLER_55_508 VGND VGND VPWR VPWR sky130_fd_sc_hd__decap_3
XFILLER_94_121 VGND VGND VPWR VPWR sky130_fd_sc_hd__decap_3
XFILLER_67_379 VGND VGND VPWR VPWR sky130_fd_sc_hd__decap_3
XFILLER_35_221 VGND VGND VPWR VPWR sky130_fd_sc_hd__decap_3
XFILLER_75_390 VGND VGND VPWR VPWR sky130_fd_sc_hd__fill_2
XFILLER_23_405 VGND VGND VPWR VPWR sky130_fd_sc_hd__decap_3
X_6821_ clkload8/A _6821_/D VGND VGND VPWR VPWR _6821_/Q sky130_fd_sc_hd__dfxtp_2
XTAP_TAPCELL_ROW_46_761 VGND VPWR sky130_fd_sc_hd__tapvpwrvgnd_1
XTAP_TAPCELL_ROW_18_441 VGND VPWR sky130_fd_sc_hd__tapvpwrvgnd_1
XFILLER_35_276 VGND VGND VPWR VPWR sky130_fd_sc_hd__decap_3
XFILLER_90_371 VGND VGND VPWR VPWR sky130_fd_sc_hd__fill_2
Xclkbuf_leaf_15_clk clkload1/A VGND VGND VPWR VPWR _7083_/CLK sky130_fd_sc_hd__clkbuf_16
X_6752_ clkload8/A _6752_/D VGND VGND VPWR VPWR _6752_/Q sky130_fd_sc_hd__dfxtp_2
X_3964_ _7358_/Q _4507_/A0 _3975_/S VGND VGND VPWR VPWR _3964_/X sky130_fd_sc_hd__mux2_2
XFILLER_31_460 VGND VGND VPWR VPWR sky130_fd_sc_hd__decap_3
X_6683_ _6684_/A VGND VGND VPWR VPWR _6683_/Y sky130_fd_sc_hd__inv_2
X_5703_ _7357_/Q hold920/X _5721_/S VGND VGND VPWR VPWR _6701_/D sky130_fd_sc_hd__mux2_2
X_3895_ _3927_/A1 _3887_/X _3889_/X _3741_/X _3894_/X VGND VGND VPWR VPWR _3895_/X
+ sky130_fd_sc_hd__a221o_2
XFILLER_31_482 VGND VGND VPWR VPWR sky130_fd_sc_hd__fill_2
XFILLER_31_493 VGND VGND VPWR VPWR sky130_fd_sc_hd__fill_2
X_5634_ _5634_/A _5634_/B VGND VGND VPWR VPWR _7011_/D sky130_fd_sc_hd__and2_2
X_7304_ _7374_/CLK _7304_/D _6584_/Y VGND VGND VPWR VPWR _7304_/Q sky130_fd_sc_hd__dfrtp_2
XFILLER_2_309 VGND VGND VPWR VPWR sky130_fd_sc_hd__fill_2
XFILLER_104_237 VGND VGND VPWR VPWR sky130_fd_sc_hd__decap_3
X_7235_ _7374_/CLK _7235_/D _6515_/Y VGND VGND VPWR VPWR _7235_/Q sky130_fd_sc_hd__dfrtp_2
X_4447_ _4447_/A _4447_/B VGND VGND VPWR VPWR _4447_/Y sky130_fd_sc_hd__nor2_2
X_7166_ _7362_/CLK _7166_/D _6446_/Y VGND VGND VPWR VPWR _7166_/Q sky130_fd_sc_hd__dfrtp_2
XFILLER_58_302 VGND VGND VPWR VPWR sky130_fd_sc_hd__decap_3
XFILLER_86_622 VGND VGND VPWR VPWR sky130_fd_sc_hd__fill_1
X_4378_ _4243_/Y _4277_/Y _5032_/B _4377_/Y VGND VGND VPWR VPWR _4968_/A sky130_fd_sc_hd__a31o_4
XFILLER_98_482 VGND VGND VPWR VPWR sky130_fd_sc_hd__decap_3
XFILLER_100_432 VGND VGND VPWR VPWR sky130_fd_sc_hd__decap_3
X_7097_ _7356_/CLK _7097_/D _6377_/Y VGND VGND VPWR VPWR _7097_/Q sky130_fd_sc_hd__dfrtp_2
X_3329_ _3340_/A _3340_/C VGND VGND VPWR VPWR _3329_/Y sky130_fd_sc_hd__nand2_2
XFILLER_58_368 VGND VGND VPWR VPWR sky130_fd_sc_hd__decap_3
XFILLER_58_379 VGND VGND VPWR VPWR sky130_fd_sc_hd__decap_3
XFILLER_85_154 VGND VGND VPWR VPWR sky130_fd_sc_hd__decap_3
XFILLER_85_176 VGND VGND VPWR VPWR sky130_fd_sc_hd__decap_3
XFILLER_26_221 VGND VGND VPWR VPWR sky130_fd_sc_hd__decap_3
XFILLER_37_69 VGND VGND VPWR VPWR sky130_fd_sc_hd__decap_3
XFILLER_73_349 VGND VGND VPWR VPWR sky130_fd_sc_hd__decap_3
XFILLER_14_416 VGND VGND VPWR VPWR sky130_fd_sc_hd__decap_3
XFILLER_26_265 VGND VGND VPWR VPWR sky130_fd_sc_hd__decap_3
XFILLER_54_585 VGND VGND VPWR VPWR sky130_fd_sc_hd__decap_3
XFILLER_81_393 VGND VGND VPWR VPWR sky130_fd_sc_hd__decap_3
XFILLER_22_471 VGND VGND VPWR VPWR sky130_fd_sc_hd__decap_3
XFILLER_10_622 VGND VGND VPWR VPWR sky130_fd_sc_hd__decap_3
XFILLER_6_604 VGND VGND VPWR VPWR sky130_fd_sc_hd__decap_3
XFILLER_6_637 VGND VGND VPWR VPWR sky130_fd_sc_hd__decap_3
XFILLER_108_587 VGND VGND VPWR VPWR sky130_fd_sc_hd__fill_1
XFILLER_5_169 VGND VGND VPWR VPWR sky130_fd_sc_hd__decap_3
XFILLER_1_331 VGND VGND VPWR VPWR sky130_fd_sc_hd__decap_3
XTAP_TAPCELL_ROW_73_1070 VGND VPWR sky130_fd_sc_hd__tapvpwrvgnd_1
XFILLER_77_644 VGND VGND VPWR VPWR sky130_fd_sc_hd__decap_3
XFILLER_17_210 VGND VGND VPWR VPWR sky130_fd_sc_hd__decap_3
XFILLER_91_113 VGND VGND VPWR VPWR sky130_fd_sc_hd__decap_3
XFILLER_91_124 VGND VGND VPWR VPWR sky130_fd_sc_hd__decap_3
XFILLER_60_500 VGND VGND VPWR VPWR sky130_fd_sc_hd__decap_3
XFILLER_17_298 VGND VGND VPWR VPWR sky130_fd_sc_hd__decap_3
XFILLER_32_224 VGND VGND VPWR VPWR sky130_fd_sc_hd__decap_3
XFILLER_60_533 VGND VGND VPWR VPWR sky130_fd_sc_hd__decap_3
XFILLER_60_555 VGND VGND VPWR VPWR sky130_fd_sc_hd__decap_3
XTAP_TAPCELL_ROW_43_731 VGND VPWR sky130_fd_sc_hd__tapvpwrvgnd_1
XTAP_TAPCELL_ROW_15_411 VGND VPWR sky130_fd_sc_hd__tapvpwrvgnd_1
XFILLER_20_408 VGND VGND VPWR VPWR sky130_fd_sc_hd__decap_3
XFILLER_9_420 VGND VGND VPWR VPWR sky130_fd_sc_hd__fill_1
X_3680_ _3677_/Y _3912_/A2 _3912_/B1 _3679_/Y VGND VGND VPWR VPWR _3680_/X sky130_fd_sc_hd__a22o_2
XFILLER_9_497 VGND VGND VPWR VPWR sky130_fd_sc_hd__decap_3
XFILLER_57_3 VGND VGND VPWR VPWR sky130_fd_sc_hd__decap_3
X_5350_ _5350_/A0 _5131_/X _7412_/A VGND VGND VPWR VPWR _7156_/D sky130_fd_sc_hd__mux2_2
X_4301_ _7352_/Q _4346_/B1 _4348_/A2 _7160_/Q _4300_/X VGND VGND VPWR VPWR _4301_/X
+ sky130_fd_sc_hd__a221o_2
XFILLER_4_180 VGND VGND VPWR VPWR sky130_fd_sc_hd__decap_3
XFILLER_87_408 VGND VGND VPWR VPWR sky130_fd_sc_hd__decap_3
X_7020_ _7372_/CLK _7020_/D _6300_/Y VGND VGND VPWR VPWR _7020_/Q sky130_fd_sc_hd__dfrtp_2
X_4232_ _4228_/X _4231_/X _4327_/A VGND VGND VPWR VPWR _4628_/A sky130_fd_sc_hd__o21a_2
XFILLER_101_218 VGND VGND VPWR VPWR sky130_fd_sc_hd__decap_3
Xclkbuf_leaf_4_clk clkbuf_leaf_7_clk/A VGND VGND VPWR VPWR clkload7/A sky130_fd_sc_hd__clkbuf_16
XFILLER_99_279 VGND VGND VPWR VPWR sky130_fd_sc_hd__fill_1
XFILLER_68_633 VGND VGND VPWR VPWR sky130_fd_sc_hd__decap_3
X_4163_ _7073_/Q _4265_/B _4205_/A VGND VGND VPWR VPWR _4203_/B sky130_fd_sc_hd__o21a_2
XFILLER_28_519 VGND VGND VPWR VPWR sky130_fd_sc_hd__decap_3
XFILLER_55_305 VGND VGND VPWR VPWR sky130_fd_sc_hd__decap_3
XFILLER_67_143 VGND VGND VPWR VPWR sky130_fd_sc_hd__decap_3
XFILLER_82_102 VGND VGND VPWR VPWR sky130_fd_sc_hd__decap_3
X_4094_ _4095_/A _4210_/B VGND VGND VPWR VPWR _4096_/A sky130_fd_sc_hd__or2_2
XFILLER_95_485 VGND VGND VPWR VPWR sky130_fd_sc_hd__fill_1
XFILLER_95_452 VGND VGND VPWR VPWR sky130_fd_sc_hd__decap_3
XFILLER_55_349 VGND VGND VPWR VPWR sky130_fd_sc_hd__decap_3
XFILLER_67_187 VGND VGND VPWR VPWR sky130_fd_sc_hd__decap_3
XFILLER_83_647 VGND VGND VPWR VPWR sky130_fd_sc_hd__fill_1
XTAP_TAPCELL_ROW_87_1239 VGND VPWR sky130_fd_sc_hd__tapvpwrvgnd_1
XFILLER_36_563 VGND VGND VPWR VPWR sky130_fd_sc_hd__decap_3
XFILLER_51_500 VGND VGND VPWR VPWR sky130_fd_sc_hd__decap_3
XFILLER_23_235 VGND VGND VPWR VPWR sky130_fd_sc_hd__decap_3
XFILLER_51_555 VGND VGND VPWR VPWR sky130_fd_sc_hd__decap_3
XFILLER_63_393 VGND VGND VPWR VPWR sky130_fd_sc_hd__decap_3
XFILLER_90_190 VGND VGND VPWR VPWR sky130_fd_sc_hd__decap_3
Xplace382 _4341_/B1 VGND VGND VPWR VPWR _4348_/B1 sky130_fd_sc_hd__buf_2
Xplace371 _5151_/A VGND VGND VPWR VPWR _3896_/B1 sky130_fd_sc_hd__buf_2
Xplace360 _4352_/B1 VGND VGND VPWR VPWR _4436_/B1 sky130_fd_sc_hd__buf_2
X_6804_ _6943_/CLK _6804_/D VGND VGND VPWR VPWR _6804_/Q sky130_fd_sc_hd__dfxtp_2
X_4996_ _4799_/A _5657_/D _3817_/X _3346_/A VGND VGND VPWR VPWR _4996_/X sky130_fd_sc_hd__o211a_2
XFILLER_11_408 VGND VGND VPWR VPWR sky130_fd_sc_hd__decap_3
XFILLER_23_268 VGND VGND VPWR VPWR sky130_fd_sc_hd__decap_3
Xplace393 _5310_/S VGND VGND VPWR VPWR _5333_/S sky130_fd_sc_hd__buf_2
X_6735_ clkload7/A _6735_/D VGND VGND VPWR VPWR _6735_/Q sky130_fd_sc_hd__dfxtp_2
X_3947_ _7366_/Q _4491_/A0 _3956_/S VGND VGND VPWR VPWR _7366_/D sky130_fd_sc_hd__mux2_2
X_6666_ _6668_/A VGND VGND VPWR VPWR _6666_/Y sky130_fd_sc_hd__inv_2
X_3878_ _6729_/Q _3913_/B1 _3881_/B1 _6741_/Q VGND VGND VPWR VPWR _3878_/X sky130_fd_sc_hd__a22o_2
X_6597_ _6598_/A VGND VGND VPWR VPWR _6597_/Y sky130_fd_sc_hd__inv_2
X_5617_ _5617_/A _5634_/B VGND VGND VPWR VPWR _7019_/D sky130_fd_sc_hd__and2_2
XTAP_TAPCELL_ROW_98_1357 VGND VPWR sky130_fd_sc_hd__tapvpwrvgnd_1
XFILLER_3_629 VGND VGND VPWR VPWR sky130_fd_sc_hd__decap_3
X_7218_ _7355_/CLK _7218_/D _6498_/Y VGND VGND VPWR VPWR _7218_/Q sky130_fd_sc_hd__dfrtp_2
XFILLER_78_419 VGND VGND VPWR VPWR sky130_fd_sc_hd__fill_1
XFILLER_58_121 VGND VGND VPWR VPWR sky130_fd_sc_hd__fill_2
XFILLER_59_644 VGND VGND VPWR VPWR sky130_fd_sc_hd__decap_3
XFILLER_86_430 VGND VGND VPWR VPWR sky130_fd_sc_hd__decap_3
X_7149_ _7373_/CLK _7149_/D _6429_/Y VGND VGND VPWR VPWR _7149_/Q sky130_fd_sc_hd__dfrtp_2
XFILLER_19_508 VGND VGND VPWR VPWR sky130_fd_sc_hd__decap_3
XFILLER_58_187 VGND VGND VPWR VPWR sky130_fd_sc_hd__decap_3
XFILLER_73_113 VGND VGND VPWR VPWR sky130_fd_sc_hd__decap_3
XFILLER_74_636 VGND VGND VPWR VPWR sky130_fd_sc_hd__decap_3
XFILLER_86_485 VGND VGND VPWR VPWR sky130_fd_sc_hd__decap_3
XFILLER_104_85 VGND VGND VPWR VPWR sky130_fd_sc_hd__decap_3
XFILLER_64_23 VGND VGND VPWR VPWR sky130_fd_sc_hd__decap_3
XFILLER_64_45 VGND VGND VPWR VPWR sky130_fd_sc_hd__decap_3
XTAP_TAPCELL_ROW_29_569 VGND VPWR sky130_fd_sc_hd__tapvpwrvgnd_1
XFILLER_27_585 VGND VGND VPWR VPWR sky130_fd_sc_hd__decap_3
XFILLER_54_382 VGND VGND VPWR VPWR sky130_fd_sc_hd__decap_3
XFILLER_61_319 VGND VGND VPWR VPWR sky130_fd_sc_hd__decap_3
XTAP_TAPCELL_ROW_57_889 VGND VPWR sky130_fd_sc_hd__tapvpwrvgnd_1
XTAP_TAPCELL_ROW_107_1464 VGND VPWR sky130_fd_sc_hd__tapvpwrvgnd_1
XFILLER_42_533 VGND VGND VPWR VPWR sky130_fd_sc_hd__decap_3
XFILLER_81_190 VGND VGND VPWR VPWR sky130_fd_sc_hd__decap_3
Xfanout50 _6685_/A VGND VGND VPWR VPWR _6677_/A sky130_fd_sc_hd__buf_2
Xfanout61 _6616_/A VGND VGND VPWR VPWR _6611_/A sky130_fd_sc_hd__buf_1
Xfanout72 _6278_/A VGND VGND VPWR VPWR _6397_/A sky130_fd_sc_hd__buf_2
XFILLER_10_430 VGND VGND VPWR VPWR sky130_fd_sc_hd__decap_3
XFILLER_80_88 VGND VGND VPWR VPWR sky130_fd_sc_hd__decap_3
XFILLER_80_99 VGND VGND VPWR VPWR sky130_fd_sc_hd__decap_3
XFILLER_10_474 VGND VGND VPWR VPWR sky130_fd_sc_hd__fill_2
XFILLER_13_71 VGND VGND VPWR VPWR sky130_fd_sc_hd__decap_3
XFILLER_89_20 VGND VGND VPWR VPWR sky130_fd_sc_hd__fill_1
XFILLER_89_42 VGND VGND VPWR VPWR sky130_fd_sc_hd__decap_3
XFILLER_2_640 VGND VGND VPWR VPWR sky130_fd_sc_hd__decap_3
XFILLER_1_172 VGND VGND VPWR VPWR sky130_fd_sc_hd__decap_3
XFILLER_49_121 VGND VGND VPWR VPWR sky130_fd_sc_hd__decap_3
XFILLER_37_305 VGND VGND VPWR VPWR sky130_fd_sc_hd__decap_3
XFILLER_49_154 VGND VGND VPWR VPWR sky130_fd_sc_hd__decap_3
XFILLER_65_614 VGND VGND VPWR VPWR sky130_fd_sc_hd__fill_2
XFILLER_49_187 VGND VGND VPWR VPWR sky130_fd_sc_hd__decap_3
XFILLER_65_647 VGND VGND VPWR VPWR sky130_fd_sc_hd__fill_1
XFILLER_77_496 VGND VGND VPWR VPWR sky130_fd_sc_hd__decap_3
XFILLER_18_552 VGND VGND VPWR VPWR sky130_fd_sc_hd__decap_3
XFILLER_64_157 VGND VGND VPWR VPWR sky130_fd_sc_hd__decap_3
XFILLER_92_477 VGND VGND VPWR VPWR sky130_fd_sc_hd__fill_1
Xclkbuf_3_7__f_clk clkbuf_0_clk/X VGND VGND VPWR VPWR clkload2/A sky130_fd_sc_hd__clkbuf_16
XFILLER_33_500 VGND VGND VPWR VPWR sky130_fd_sc_hd__fill_1
XFILLER_60_341 VGND VGND VPWR VPWR sky130_fd_sc_hd__fill_2
XFILLER_72_190 VGND VGND VPWR VPWR sky130_fd_sc_hd__decap_3
X_4850_ _4142_/X _4849_/Y _4633_/A VGND VGND VPWR VPWR _4850_/Y sky130_fd_sc_hd__o21ai_2
X_3801_ _3735_/X _3798_/X _3800_/X _3714_/X VGND VGND VPWR VPWR _3801_/X sky130_fd_sc_hd__a22o_2
XFILLER_20_227 VGND VGND VPWR VPWR sky130_fd_sc_hd__decap_3
X_6520_ _6618_/A VGND VGND VPWR VPWR _6520_/Y sky130_fd_sc_hd__inv_2
X_4781_ _4444_/X _4780_/Y _4413_/A VGND VGND VPWR VPWR _4781_/X sky130_fd_sc_hd__o21a_2
X_3732_ _6776_/Q _3884_/A2 _3824_/B1 _6764_/Q _3731_/X VGND VGND VPWR VPWR _3732_/X
+ sky130_fd_sc_hd__a221o_2
Xclkload20 _7387_/CLK VGND VGND VPWR VPWR clkload20/X sky130_fd_sc_hd__clkbuf_1
X_6451_ _6646_/A VGND VGND VPWR VPWR _6451_/Y sky130_fd_sc_hd__inv_2
Xclkload31 _7269_/CLK VGND VGND VPWR VPWR clkload31/Y sky130_fd_sc_hd__clkinv_2
X_6382_ _6601_/A VGND VGND VPWR VPWR _6382_/Y sky130_fd_sc_hd__inv_2
X_5402_ _5402_/A0 _5027_/X _5427_/S VGND VGND VPWR VPWR _7132_/D sky130_fd_sc_hd__mux2_2
X_5333_ _5333_/A0 _5027_/X _5333_/S VGND VGND VPWR VPWR _7164_/D sky130_fd_sc_hd__mux2_2
X_3594_ _4292_/A _3594_/B VGND VGND VPWR VPWR _3594_/Y sky130_fd_sc_hd__nor2_2
X_5264_ hold990/X _4997_/X _5276_/S VGND VGND VPWR VPWR _7198_/D sky130_fd_sc_hd__mux2_2
X_7003_ _7374_/CLK _7003_/D _6283_/Y VGND VGND VPWR VPWR _7003_/Q sky130_fd_sc_hd__dfrtp_2
X_4215_ _7260_/Q _4260_/A2 _4212_/X _4214_/X VGND VGND VPWR VPWR _4371_/A sky130_fd_sc_hd__a211o_2
XFILLER_28_305 VGND VGND VPWR VPWR sky130_fd_sc_hd__decap_3
X_4146_ _7234_/Q _4214_/A2 _4428_/B1 _7138_/Q VGND VGND VPWR VPWR _4146_/X sky130_fd_sc_hd__a22o_2
XFILLER_18_27 VGND VGND VPWR VPWR sky130_fd_sc_hd__fill_1
XFILLER_56_636 VGND VGND VPWR VPWR sky130_fd_sc_hd__decap_3
XFILLER_95_293 VGND VGND VPWR VPWR sky130_fd_sc_hd__decap_3
XFILLER_83_466 VGND VGND VPWR VPWR sky130_fd_sc_hd__fill_2
X_4077_ _7243_/Q _4414_/A2 _4434_/A2 _7115_/Q _4076_/X VGND VGND VPWR VPWR _4077_/X
+ sky130_fd_sc_hd__a221o_2
XFILLER_36_371 VGND VGND VPWR VPWR sky130_fd_sc_hd__decap_3
XTAP_TAPCELL_ROW_26_528 VGND VPWR sky130_fd_sc_hd__tapvpwrvgnd_1
XFILLER_24_555 VGND VGND VPWR VPWR sky130_fd_sc_hd__decap_3
XFILLER_70_127 VGND VGND VPWR VPWR sky130_fd_sc_hd__decap_3
XTAP_TAPCELL_ROW_54_859 VGND VPWR sky130_fd_sc_hd__tapvpwrvgnd_1
XTAP_TAPCELL_ROW_26_539 VGND VPWR sky130_fd_sc_hd__tapvpwrvgnd_1
XFILLER_51_374 VGND VGND VPWR VPWR sky130_fd_sc_hd__decap_3
X_4979_ _4979_/A0 _4978_/X _4998_/S VGND VGND VPWR VPWR _7263_/D sky130_fd_sc_hd__mux2_2
Xclkload3 clkload3/A VGND VGND VPWR VPWR clkload3/X sky130_fd_sc_hd__clkbuf_8
X_6718_ _7083_/CLK _6718_/D VGND VGND VPWR VPWR _6718_/Q sky130_fd_sc_hd__dfxtp_2
X_6649_ _6686_/A VGND VGND VPWR VPWR _6649_/Y sky130_fd_sc_hd__inv_2
XFILLER_3_426 VGND VGND VPWR VPWR sky130_fd_sc_hd__fill_2
XFILLER_105_343 VGND VGND VPWR VPWR sky130_fd_sc_hd__fill_1
XFILLER_3_437 VGND VGND VPWR VPWR sky130_fd_sc_hd__decap_3
XFILLER_105_365 VGND VGND VPWR VPWR sky130_fd_sc_hd__decap_3
XFILLER_78_216 VGND VGND VPWR VPWR sky130_fd_sc_hd__decap_3
XTAP_TAPCELL_ROW_70_1040 VGND VPWR sky130_fd_sc_hd__tapvpwrvgnd_1
XFILLER_59_452 VGND VGND VPWR VPWR sky130_fd_sc_hd__decap_3
XFILLER_19_316 VGND VGND VPWR VPWR sky130_fd_sc_hd__decap_3
XFILLER_46_124 VGND VGND VPWR VPWR sky130_fd_sc_hd__decap_3
XFILLER_47_647 VGND VGND VPWR VPWR sky130_fd_sc_hd__fill_1
XFILLER_86_271 VGND VGND VPWR VPWR sky130_fd_sc_hd__decap_3
XFILLER_19_349 VGND VGND VPWR VPWR sky130_fd_sc_hd__decap_3
XFILLER_75_88 VGND VGND VPWR VPWR sky130_fd_sc_hd__decap_3
XFILLER_46_179 VGND VGND VPWR VPWR sky130_fd_sc_hd__decap_3
XFILLER_62_639 VGND VGND VPWR VPWR sky130_fd_sc_hd__decap_3
XFILLER_27_393 VGND VGND VPWR VPWR sky130_fd_sc_hd__fill_2
XFILLER_54_190 VGND VGND VPWR VPWR sky130_fd_sc_hd__decap_3
XFILLER_15_588 VGND VGND VPWR VPWR sky130_fd_sc_hd__decap_3
XFILLER_42_352 VGND VGND VPWR VPWR sky130_fd_sc_hd__fill_1
XFILLER_91_54 VGND VGND VPWR VPWR sky130_fd_sc_hd__fill_2
XFILLER_30_536 VGND VGND VPWR VPWR sky130_fd_sc_hd__decap_3
XFILLER_42_374 VGND VGND VPWR VPWR sky130_fd_sc_hd__fill_1
XFILLER_91_98 VGND VGND VPWR VPWR sky130_fd_sc_hd__decap_3
XFILLER_10_271 VGND VGND VPWR VPWR sky130_fd_sc_hd__decap_3
XFILLER_6_253 VGND VGND VPWR VPWR sky130_fd_sc_hd__decap_3
XFILLER_6_275 VGND VGND VPWR VPWR sky130_fd_sc_hd__decap_3
XFILLER_40_91 VGND VGND VPWR VPWR sky130_fd_sc_hd__fill_2
XFILLER_69_205 VGND VGND VPWR VPWR sky130_fd_sc_hd__fill_1
XFILLER_97_558 VGND VGND VPWR VPWR sky130_fd_sc_hd__fill_2
XFILLER_38_603 VGND VGND VPWR VPWR sky130_fd_sc_hd__decap_3
XFILLER_84_208 VGND VGND VPWR VPWR sky130_fd_sc_hd__fill_2
XFILLER_38_636 VGND VGND VPWR VPWR sky130_fd_sc_hd__decap_3
XFILLER_65_433 VGND VGND VPWR VPWR sky130_fd_sc_hd__decap_3
XFILLER_77_271 VGND VGND VPWR VPWR sky130_fd_sc_hd__decap_3
XFILLER_1_63 VGND VGND VPWR VPWR sky130_fd_sc_hd__fill_1
XFILLER_37_157 VGND VGND VPWR VPWR sky130_fd_sc_hd__decap_3
XFILLER_65_444 VGND VGND VPWR VPWR sky130_fd_sc_hd__fill_1
XFILLER_53_617 VGND VGND VPWR VPWR sky130_fd_sc_hd__decap_3
XFILLER_65_499 VGND VGND VPWR VPWR sky130_fd_sc_hd__decap_3
XFILLER_52_127 VGND VGND VPWR VPWR sky130_fd_sc_hd__decap_3
XFILLER_52_149 VGND VGND VPWR VPWR sky130_fd_sc_hd__decap_3
XFILLER_92_296 VGND VGND VPWR VPWR sky130_fd_sc_hd__decap_3
XTAP_TAPCELL_ROW_51_818 VGND VPWR sky130_fd_sc_hd__tapvpwrvgnd_1
XFILLER_21_536 VGND VGND VPWR VPWR sky130_fd_sc_hd__decap_3
X_4833_ _7001_/Q _4687_/B _4777_/A VGND VGND VPWR VPWR _4834_/B sky130_fd_sc_hd__o21ai_2
X_4764_ _4938_/A _4764_/B VGND VGND VPWR VPWR _4764_/Y sky130_fd_sc_hd__nor2_2
X_6503_ _6624_/A VGND VGND VPWR VPWR _6503_/Y sky130_fd_sc_hd__inv_2
XTAP_TAPCELL_ROW_31_586 VGND VPWR sky130_fd_sc_hd__tapvpwrvgnd_1
X_6434_ _6592_/A VGND VGND VPWR VPWR _6434_/Y sky130_fd_sc_hd__inv_2
X_4695_ _7008_/Q _4728_/A _4694_/Y _4909_/A VGND VGND VPWR VPWR _4695_/X sky130_fd_sc_hd__a211o_2
XTAP_TAPCELL_ROW_95_1327 VGND VPWR sky130_fd_sc_hd__tapvpwrvgnd_1
X_6365_ _6685_/A VGND VGND VPWR VPWR _6365_/Y sky130_fd_sc_hd__inv_2
X_3577_ _7060_/Q _4305_/B VGND VGND VPWR VPWR _3591_/C sky130_fd_sc_hd__nor2_2
X_6296_ _6601_/A VGND VGND VPWR VPWR _6296_/Y sky130_fd_sc_hd__inv_2
XFILLER_102_324 VGND VGND VPWR VPWR sky130_fd_sc_hd__decap_3
XFILLER_88_536 VGND VGND VPWR VPWR sky130_fd_sc_hd__decap_3
X_5247_ _5247_/A0 _4864_/X _5274_/S VGND VGND VPWR VPWR _7206_/D sky130_fd_sc_hd__mux2_2
XFILLER_102_379 VGND VGND VPWR VPWR sky130_fd_sc_hd__decap_3
XFILLER_75_208 VGND VGND VPWR VPWR sky130_fd_sc_hd__decap_3
XTAP_TAPCELL_ROW_59_918 VGND VPWR sky130_fd_sc_hd__tapvpwrvgnd_1
XFILLER_29_614 VGND VGND VPWR VPWR sky130_fd_sc_hd__fill_2
XFILLER_29_647 VGND VGND VPWR VPWR sky130_fd_sc_hd__fill_1
XFILLER_68_293 VGND VGND VPWR VPWR sky130_fd_sc_hd__fill_2
X_4129_ _7299_/Q _4478_/S _4419_/B1 _7363_/Q _4429_/C1 VGND VGND VPWR VPWR _4129_/X
+ sky130_fd_sc_hd__a221o_2
XTAP_TAPCELL_ROW_3_267 VGND VPWR sky130_fd_sc_hd__tapvpwrvgnd_1
XFILLER_43_105 VGND VGND VPWR VPWR sky130_fd_sc_hd__decap_3
XFILLER_43_116 VGND VGND VPWR VPWR sky130_fd_sc_hd__decap_3
XFILLER_44_628 VGND VGND VPWR VPWR sky130_fd_sc_hd__decap_3
XFILLER_71_425 VGND VGND VPWR VPWR sky130_fd_sc_hd__fill_1
XFILLER_83_274 VGND VGND VPWR VPWR sky130_fd_sc_hd__decap_3
XTAP_TAPCELL_ROW_39_686 VGND VPWR sky130_fd_sc_hd__tapvpwrvgnd_1
XFILLER_45_69 VGND VGND VPWR VPWR sky130_fd_sc_hd__fill_2
XFILLER_71_447 VGND VGND VPWR VPWR sky130_fd_sc_hd__fill_1
XFILLER_83_296 VGND VGND VPWR VPWR sky130_fd_sc_hd__decap_3
XTAP_TAPCELL_ROW_104_1434 VGND VPWR sky130_fd_sc_hd__tapvpwrvgnd_1
XFILLER_101_53 VGND VGND VPWR VPWR sky130_fd_sc_hd__decap_3
XFILLER_12_536 VGND VGND VPWR VPWR sky130_fd_sc_hd__decap_3
XFILLER_12_558 VGND VGND VPWR VPWR sky130_fd_sc_hd__decap_3
XFILLER_61_57 VGND VGND VPWR VPWR sky130_fd_sc_hd__decap_3
XFILLER_61_79 VGND VGND VPWR VPWR sky130_fd_sc_hd__decap_3
XFILLER_20_580 VGND VGND VPWR VPWR sky130_fd_sc_hd__decap_3
XFILLER_3_234 VGND VGND VPWR VPWR sky130_fd_sc_hd__decap_3
XFILLER_105_151 VGND VGND VPWR VPWR sky130_fd_sc_hd__decap_3
XFILLER_3_256 VGND VGND VPWR VPWR sky130_fd_sc_hd__decap_3
XFILLER_79_503 VGND VGND VPWR VPWR sky130_fd_sc_hd__fill_1
XFILLER_79_514 VGND VGND VPWR VPWR sky130_fd_sc_hd__decap_3
XFILLER_79_547 VGND VGND VPWR VPWR sky130_fd_sc_hd__decap_3
XFILLER_19_113 VGND VGND VPWR VPWR sky130_fd_sc_hd__fill_1
XFILLER_101_390 VGND VGND VPWR VPWR sky130_fd_sc_hd__fill_2
XFILLER_19_146 VGND VGND VPWR VPWR sky130_fd_sc_hd__decap_3
XFILLER_19_92 VGND VGND VPWR VPWR sky130_fd_sc_hd__decap_3
XFILLER_35_617 VGND VGND VPWR VPWR sky130_fd_sc_hd__decap_3
XFILLER_47_477 VGND VGND VPWR VPWR sky130_fd_sc_hd__decap_3
XFILLER_74_263 VGND VGND VPWR VPWR sky130_fd_sc_hd__fill_2
XFILLER_15_352 VGND VGND VPWR VPWR sky130_fd_sc_hd__fill_2
XFILLER_15_363 VGND VGND VPWR VPWR sky130_fd_sc_hd__decap_3
XFILLER_15_396 VGND VGND VPWR VPWR sky130_fd_sc_hd__decap_3
XFILLER_42_160 VGND VGND VPWR VPWR sky130_fd_sc_hd__decap_3
XFILLER_42_182 VGND VGND VPWR VPWR sky130_fd_sc_hd__decap_3
XFILLER_70_480 VGND VGND VPWR VPWR sky130_fd_sc_hd__decap_3
XFILLER_11_591 VGND VGND VPWR VPWR sky130_fd_sc_hd__decap_3
XFILLER_7_540 VGND VGND VPWR VPWR sky130_fd_sc_hd__decap_3
X_3500_ _4460_/A _4460_/B _3541_/B VGND VGND VPWR VPWR _3500_/Y sky130_fd_sc_hd__a21oi_2
XFILLER_7_573 VGND VGND VPWR VPWR sky130_fd_sc_hd__decap_3
X_4480_ _4480_/A0 _7307_/Q _4488_/S VGND VGND VPWR VPWR _7339_/D sky130_fd_sc_hd__mux2_2
X_3362_ _5129_/B _6983_/Q _3561_/A VGND VGND VPWR VPWR _3362_/X sky130_fd_sc_hd__or3b_2
X_5101_ _5101_/A _5101_/B VGND VGND VPWR VPWR _5101_/Y sky130_fd_sc_hd__nor2_2
XFILLER_97_311 VGND VGND VPWR VPWR sky130_fd_sc_hd__decap_3
XFILLER_57_208 VGND VGND VPWR VPWR sky130_fd_sc_hd__decap_3
XFILLER_85_517 VGND VGND VPWR VPWR sky130_fd_sc_hd__decap_3
Xhold1207 _7220_/Q VGND VGND VPWR VPWR _5217_/A sky130_fd_sc_hd__dlygate4sd3_1
XTAP_TAPCELL_ROW_90_1268 VGND VPWR sky130_fd_sc_hd__tapvpwrvgnd_1
XFILLER_97_355 VGND VGND VPWR VPWR sky130_fd_sc_hd__decap_3
Xhold1218 _7165_/Q VGND VGND VPWR VPWR _5331_/A0 sky130_fd_sc_hd__dlygate4sd3_1
X_5032_ _5032_/A _5032_/B VGND VGND VPWR VPWR _5032_/Y sky130_fd_sc_hd__xnor2_2
XFILLER_97_399 VGND VGND VPWR VPWR sky130_fd_sc_hd__decap_3
XFILLER_93_550 VGND VGND VPWR VPWR sky130_fd_sc_hd__fill_1
XFILLER_25_105 VGND VGND VPWR VPWR sky130_fd_sc_hd__decap_3
XFILLER_26_617 VGND VGND VPWR VPWR sky130_fd_sc_hd__decap_3
XFILLER_38_477 VGND VGND VPWR VPWR sky130_fd_sc_hd__decap_3
XFILLER_65_252 VGND VGND VPWR VPWR sky130_fd_sc_hd__fill_2
XFILLER_80_200 VGND VGND VPWR VPWR sky130_fd_sc_hd__decap_3
XFILLER_93_561 VGND VGND VPWR VPWR sky130_fd_sc_hd__fill_1
XFILLER_93_583 VGND VGND VPWR VPWR sky130_fd_sc_hd__decap_3
XTAP_TAPCELL_ROW_0_226 VGND VPWR sky130_fd_sc_hd__tapvpwrvgnd_1
XFILLER_53_425 VGND VGND VPWR VPWR sky130_fd_sc_hd__decap_3
XFILLER_65_296 VGND VGND VPWR VPWR sky130_fd_sc_hd__decap_3
X_6983_ _7382_/CLK _6983_/D _6263_/Y VGND VGND VPWR VPWR _6983_/Q sky130_fd_sc_hd__dfrtp_2
XTAP_TAPCELL_ROW_36_645 VGND VPWR sky130_fd_sc_hd__tapvpwrvgnd_1
XTAP_TAPCELL_ROW_0_237 VGND VPWR sky130_fd_sc_hd__tapvpwrvgnd_1
XFILLER_53_469 VGND VGND VPWR VPWR sky130_fd_sc_hd__decap_3
XTAP_TAPCELL_ROW_64_976 VGND VPWR sky130_fd_sc_hd__tapvpwrvgnd_1
XTAP_TAPCELL_ROW_64_965 VGND VPWR sky130_fd_sc_hd__tapvpwrvgnd_1
XFILLER_40_119 VGND VGND VPWR VPWR sky130_fd_sc_hd__decap_3
X_4816_ _5006_/A1 _4652_/A _4813_/A _5033_/B2 VGND VGND VPWR VPWR _4816_/X sky130_fd_sc_hd__a22o_2
X_4747_ _4739_/Y _4740_/X _4743_/X _4746_/X VGND VGND VPWR VPWR _5664_/B sky130_fd_sc_hd__o211a_2
XFILLER_107_405 VGND VGND VPWR VPWR sky130_fd_sc_hd__decap_3
XFILLER_107_416 VGND VGND VPWR VPWR sky130_fd_sc_hd__decap_3
X_4678_ _6988_/Q _4674_/X _5045_/B _5036_/A VGND VGND VPWR VPWR _5014_/B sky130_fd_sc_hd__a31o_2
X_7397_ _7397_/CLK _7397_/D _6677_/Y VGND VGND VPWR VPWR _7397_/Q sky130_fd_sc_hd__dfrtp_2
X_6417_ _6646_/A VGND VGND VPWR VPWR _6417_/Y sky130_fd_sc_hd__inv_2
X_3629_ _3682_/A VGND VGND VPWR VPWR _3629_/Y sky130_fd_sc_hd__inv_2
X_6348_ _6668_/A VGND VGND VPWR VPWR _6348_/Y sky130_fd_sc_hd__inv_2
XTAP_TAPCELL_ROW_8_326 VGND VPWR sky130_fd_sc_hd__tapvpwrvgnd_1
XFILLER_103_644 VGND VGND VPWR VPWR sky130_fd_sc_hd__decap_3
XFILLER_88_333 VGND VGND VPWR VPWR sky130_fd_sc_hd__decap_3
XFILLER_0_248 VGND VGND VPWR VPWR sky130_fd_sc_hd__decap_3
XFILLER_0_259 VGND VGND VPWR VPWR sky130_fd_sc_hd__fill_2
X_6279_ _6558_/A VGND VGND VPWR VPWR _6279_/Y sky130_fd_sc_hd__inv_2
XFILLER_102_165 VGND VGND VPWR VPWR sky130_fd_sc_hd__fill_2
XFILLER_102_187 VGND VGND VPWR VPWR sky130_fd_sc_hd__decap_3
XFILLER_76_528 VGND VGND VPWR VPWR sky130_fd_sc_hd__decap_3
XFILLER_76_539 VGND VGND VPWR VPWR sky130_fd_sc_hd__decap_3
XFILLER_17_606 VGND VGND VPWR VPWR sky130_fd_sc_hd__decap_3
XFILLER_17_617 VGND VGND VPWR VPWR sky130_fd_sc_hd__decap_3
XFILLER_71_200 VGND VGND VPWR VPWR sky130_fd_sc_hd__decap_3
XFILLER_84_561 VGND VGND VPWR VPWR sky130_fd_sc_hd__decap_3
XFILLER_16_127 VGND VGND VPWR VPWR sky130_fd_sc_hd__fill_2
XFILLER_71_222 VGND VGND VPWR VPWR sky130_fd_sc_hd__fill_2
XFILLER_12_300 VGND VGND VPWR VPWR sky130_fd_sc_hd__decap_3
XFILLER_24_171 VGND VGND VPWR VPWR sky130_fd_sc_hd__decap_3
XFILLER_72_56 VGND VGND VPWR VPWR sky130_fd_sc_hd__fill_1
XFILLER_40_642 VGND VGND VPWR VPWR sky130_fd_sc_hd__fill_2
XFILLER_8_315 VGND VGND VPWR VPWR sky130_fd_sc_hd__decap_3
XFILLER_12_399 VGND VGND VPWR VPWR sky130_fd_sc_hd__decap_3
XFILLER_106_460 VGND VGND VPWR VPWR sky130_fd_sc_hd__decap_3
XFILLER_4_554 VGND VGND VPWR VPWR sky130_fd_sc_hd__decap_3
XFILLER_97_31 VGND VGND VPWR VPWR sky130_fd_sc_hd__decap_3
XFILLER_4_587 VGND VGND VPWR VPWR sky130_fd_sc_hd__fill_1
XFILLER_4_598 VGND VGND VPWR VPWR sky130_fd_sc_hd__decap_3
XFILLER_79_355 VGND VGND VPWR VPWR sky130_fd_sc_hd__decap_3
XFILLER_39_208 VGND VGND VPWR VPWR sky130_fd_sc_hd__decap_3
XFILLER_79_377 VGND VGND VPWR VPWR sky130_fd_sc_hd__fill_1
XFILLER_94_336 VGND VGND VPWR VPWR sky130_fd_sc_hd__decap_3
XFILLER_35_403 VGND VGND VPWR VPWR sky130_fd_sc_hd__decap_3
XFILLER_75_561 VGND VGND VPWR VPWR sky130_fd_sc_hd__decap_3
XFILLER_35_447 VGND VGND VPWR VPWR sky130_fd_sc_hd__fill_1
XFILLER_62_233 VGND VGND VPWR VPWR sky130_fd_sc_hd__decap_3
XFILLER_90_531 VGND VGND VPWR VPWR sky130_fd_sc_hd__fill_1
XFILLER_35_458 VGND VGND VPWR VPWR sky130_fd_sc_hd__decap_3
XFILLER_35_469 VGND VGND VPWR VPWR sky130_fd_sc_hd__decap_3
XFILLER_90_564 VGND VGND VPWR VPWR sky130_fd_sc_hd__decap_3
XFILLER_31_620 VGND VGND VPWR VPWR sky130_fd_sc_hd__decap_3
XTAP_TAPCELL_ROW_61_935 VGND VPWR sky130_fd_sc_hd__tapvpwrvgnd_1
XTAP_TAPCELL_ROW_33_615 VGND VPWR sky130_fd_sc_hd__tapvpwrvgnd_1
XFILLER_15_182 VGND VGND VPWR VPWR sky130_fd_sc_hd__fill_2
XFILLER_15_193 VGND VGND VPWR VPWR sky130_fd_sc_hd__fill_2
Xclkbuf_0_clk clk VGND VGND VPWR VPWR clkbuf_0_clk/X sky130_fd_sc_hd__clkbuf_16
X_5650_ _5650_/A VGND VGND VPWR VPWR _5650_/Y sky130_fd_sc_hd__inv_2
XFILLER_30_141 VGND VGND VPWR VPWR sky130_fd_sc_hd__decap_3
XFILLER_87_3 VGND VGND VPWR VPWR sky130_fd_sc_hd__fill_2
X_4601_ _7280_/Q _7248_/Q _4601_/S VGND VGND VPWR VPWR _7280_/D sky130_fd_sc_hd__mux2_2
XFILLER_30_174 VGND VGND VPWR VPWR sky130_fd_sc_hd__decap_3
X_5581_ hold987/X _5069_/X _5581_/S VGND VGND VPWR VPWR _7038_/D sky130_fd_sc_hd__mux2_2
XTAP_TAPCELL_ROW_13_383 VGND VPWR sky130_fd_sc_hd__tapvpwrvgnd_1
X_7320_ _7352_/CLK _7320_/D _6600_/Y VGND VGND VPWR VPWR _7320_/Q sky130_fd_sc_hd__dfrtp_2
X_4532_ _4532_/A0 _7281_/Q _4532_/S VGND VGND VPWR VPWR _4532_/X sky130_fd_sc_hd__mux2_2
X_7251_ _7349_/CLK _7251_/D _6531_/Y VGND VGND VPWR VPWR _7251_/Q sky130_fd_sc_hd__dfrtp_2
X_4463_ _4460_/Y _3541_/B _5057_/A _4462_/Y VGND VGND VPWR VPWR _4463_/X sky130_fd_sc_hd__a22o_2
XFILLER_104_408 VGND VGND VPWR VPWR sky130_fd_sc_hd__decap_3
XFILLER_89_119 VGND VGND VPWR VPWR sky130_fd_sc_hd__fill_1
X_3414_ _3421_/C VGND VGND VPWR VPWR _3449_/C sky130_fd_sc_hd__inv_4
X_7182_ _7363_/CLK _7182_/D _6462_/Y VGND VGND VPWR VPWR _7182_/Q sky130_fd_sc_hd__dfrtp_2
X_4394_ _4394_/A _4394_/B _4393_/X VGND VGND VPWR VPWR _4444_/B sky130_fd_sc_hd__or3b_2
XPHY_EDGE_ROW_15_Right_15 VGND VGND VPWR VPWR sky130_fd_sc_hd__decap_3
XFILLER_98_631 VGND VGND VPWR VPWR sky130_fd_sc_hd__decap_3
X_3345_ _5642_/A _4677_/B VGND VGND VPWR VPWR _3346_/A sky130_fd_sc_hd__nor2_4
XFILLER_97_152 VGND VGND VPWR VPWR sky130_fd_sc_hd__decap_3
XFILLER_100_636 VGND VGND VPWR VPWR sky130_fd_sc_hd__decap_3
Xhold1004 _7268_/Q VGND VGND VPWR VPWR _4901_/A0 sky130_fd_sc_hd__dlygate4sd3_1
Xhold1015 _7039_/Q VGND VGND VPWR VPWR _5579_/A0 sky130_fd_sc_hd__dlygate4sd3_1
XFILLER_85_347 VGND VGND VPWR VPWR sky130_fd_sc_hd__decap_3
XFILLER_85_358 VGND VGND VPWR VPWR sky130_fd_sc_hd__decap_3
Xhold1026 _7185_/Q VGND VGND VPWR VPWR _5288_/A0 sky130_fd_sc_hd__dlygate4sd3_1
Xhold1037 _7199_/Q VGND VGND VPWR VPWR _5262_/A0 sky130_fd_sc_hd__dlygate4sd3_1
Xhold1048 _7040_/Q VGND VGND VPWR VPWR _5577_/A0 sky130_fd_sc_hd__dlygate4sd3_1
X_5015_ _5581_/S _5015_/B _5015_/C VGND VGND VPWR VPWR _5015_/X sky130_fd_sc_hd__and3_2
Xhold1059 _7203_/Q VGND VGND VPWR VPWR _5253_/A0 sky130_fd_sc_hd__dlygate4sd3_1
XFILLER_26_436 VGND VGND VPWR VPWR sky130_fd_sc_hd__fill_1
XFILLER_38_274 VGND VGND VPWR VPWR sky130_fd_sc_hd__decap_3
XFILLER_53_211 VGND VGND VPWR VPWR sky130_fd_sc_hd__decap_3
XFILLER_26_458 VGND VGND VPWR VPWR sky130_fd_sc_hd__fill_1
XFILLER_26_49 VGND VGND VPWR VPWR sky130_fd_sc_hd__fill_2
XFILLER_53_255 VGND VGND VPWR VPWR sky130_fd_sc_hd__decap_3
X_6966_ _6966_/CLK _6966_/D VGND VGND VPWR VPWR _6966_/Q sky130_fd_sc_hd__dfxtp_2
XPHY_EDGE_ROW_24_Right_24 VGND VGND VPWR VPWR sky130_fd_sc_hd__decap_3
XFILLER_13_119 VGND VGND VPWR VPWR sky130_fd_sc_hd__fill_2
XFILLER_22_631 VGND VGND VPWR VPWR sky130_fd_sc_hd__decap_3
XFILLER_34_480 VGND VGND VPWR VPWR sky130_fd_sc_hd__decap_3
X_6897_ _6974_/CLK _6897_/D VGND VGND VPWR VPWR _6897_/Q sky130_fd_sc_hd__dfxtp_2
XFILLER_21_163 VGND VGND VPWR VPWR sky130_fd_sc_hd__decap_3
XFILLER_107_257 VGND VGND VPWR VPWR sky130_fd_sc_hd__fill_2
XPHY_EDGE_ROW_33_Right_33 VGND VGND VPWR VPWR sky130_fd_sc_hd__decap_3
XFILLER_1_535 VGND VGND VPWR VPWR sky130_fd_sc_hd__decap_3
XFILLER_89_620 VGND VGND VPWR VPWR sky130_fd_sc_hd__fill_2
Xhold860 _7101_/Q VGND VGND VPWR VPWR _7101_/D sky130_fd_sc_hd__dlygate4sd3_1
Xhold871 _7097_/Q VGND VGND VPWR VPWR _7097_/D sky130_fd_sc_hd__dlygate4sd3_1
Xhold882 _7072_/Q VGND VGND VPWR VPWR _7072_/D sky130_fd_sc_hd__dlygate4sd3_1
XFILLER_107_52 VGND VGND VPWR VPWR sky130_fd_sc_hd__decap_3
XFILLER_107_63 VGND VGND VPWR VPWR sky130_fd_sc_hd__decap_3
XFILLER_88_141 VGND VGND VPWR VPWR sky130_fd_sc_hd__decap_3
Xhold893 _7079_/Q VGND VGND VPWR VPWR _7079_/D sky130_fd_sc_hd__dlygate4sd3_1
XFILLER_1_579 VGND VGND VPWR VPWR sky130_fd_sc_hd__decap_3
XFILLER_76_325 VGND VGND VPWR VPWR sky130_fd_sc_hd__decap_3
XFILLER_88_163 VGND VGND VPWR VPWR sky130_fd_sc_hd__decap_3
XFILLER_103_496 VGND VGND VPWR VPWR sky130_fd_sc_hd__decap_3
XFILLER_76_358 VGND VGND VPWR VPWR sky130_fd_sc_hd__decap_3
XFILLER_29_252 VGND VGND VPWR VPWR sky130_fd_sc_hd__decap_3
XFILLER_57_561 VGND VGND VPWR VPWR sky130_fd_sc_hd__decap_3
XFILLER_64_509 VGND VGND VPWR VPWR sky130_fd_sc_hd__decap_3
XFILLER_17_436 VGND VGND VPWR VPWR sky130_fd_sc_hd__fill_1
XFILLER_44_200 VGND VGND VPWR VPWR sky130_fd_sc_hd__decap_3
XFILLER_44_222 VGND VGND VPWR VPWR sky130_fd_sc_hd__decap_3
XFILLER_57_583 VGND VGND VPWR VPWR sky130_fd_sc_hd__decap_3
XFILLER_83_44 VGND VGND VPWR VPWR sky130_fd_sc_hd__decap_3
XFILLER_84_380 VGND VGND VPWR VPWR sky130_fd_sc_hd__decap_3
XTAP_TAPCELL_ROW_67_1001 VGND VPWR sky130_fd_sc_hd__tapvpwrvgnd_1
XPHY_EDGE_ROW_42_Right_42 VGND VGND VPWR VPWR sky130_fd_sc_hd__decap_3
XFILLER_32_406 VGND VGND VPWR VPWR sky130_fd_sc_hd__fill_1
XFILLER_44_244 VGND VGND VPWR VPWR sky130_fd_sc_hd__decap_3
XFILLER_72_564 VGND VGND VPWR VPWR sky130_fd_sc_hd__decap_3
XFILLER_83_77 VGND VGND VPWR VPWR sky130_fd_sc_hd__decap_3
XFILLER_44_288 VGND VGND VPWR VPWR sky130_fd_sc_hd__decap_3
XFILLER_72_597 VGND VGND VPWR VPWR sky130_fd_sc_hd__decap_3
XFILLER_13_620 VGND VGND VPWR VPWR sky130_fd_sc_hd__decap_3
XPHY_EDGE_ROW_17_Left_126 VGND VGND VPWR VPWR sky130_fd_sc_hd__decap_3
XFILLER_12_141 VGND VGND VPWR VPWR sky130_fd_sc_hd__decap_3
XFILLER_9_635 VGND VGND VPWR VPWR sky130_fd_sc_hd__decap_3
XFILLER_12_174 VGND VGND VPWR VPWR sky130_fd_sc_hd__decap_3
XFILLER_12_185 VGND VGND VPWR VPWR sky130_fd_sc_hd__decap_3
XFILLER_40_494 VGND VGND VPWR VPWR sky130_fd_sc_hd__decap_3
XFILLER_8_134 VGND VGND VPWR VPWR sky130_fd_sc_hd__decap_3
XFILLER_8_156 VGND VGND VPWR VPWR sky130_fd_sc_hd__fill_2
XFILLER_8_178 VGND VGND VPWR VPWR sky130_fd_sc_hd__fill_2
XPHY_EDGE_ROW_51_Right_51 VGND VGND VPWR VPWR sky130_fd_sc_hd__decap_3
XTAP_TAPCELL_ROW_78_1130 VGND VPWR sky130_fd_sc_hd__tapvpwrvgnd_1
XTAP_TAPCELL_ROW_10_353 VGND VPWR sky130_fd_sc_hd__tapvpwrvgnd_1
XFILLER_4_351 VGND VGND VPWR VPWR sky130_fd_sc_hd__fill_1
XFILLER_4_362 VGND VGND VPWR VPWR sky130_fd_sc_hd__fill_2
XFILLER_4_384 VGND VGND VPWR VPWR sky130_fd_sc_hd__decap_3
XPHY_EDGE_ROW_26_Left_135 VGND VGND VPWR VPWR sky130_fd_sc_hd__decap_3
XFILLER_99_439 VGND VGND VPWR VPWR sky130_fd_sc_hd__decap_3
XFILLER_106_290 VGND VGND VPWR VPWR sky130_fd_sc_hd__decap_3
XFILLER_4_395 VGND VGND VPWR VPWR sky130_fd_sc_hd__fill_1
XFILLER_67_314 VGND VGND VPWR VPWR sky130_fd_sc_hd__decap_3
XFILLER_79_152 VGND VGND VPWR VPWR sky130_fd_sc_hd__fill_1
XFILLER_95_601 VGND VGND VPWR VPWR sky130_fd_sc_hd__decap_3
XFILLER_95_645 VGND VGND VPWR VPWR sky130_fd_sc_hd__decap_3
XFILLER_48_572 VGND VGND VPWR VPWR sky130_fd_sc_hd__decap_3
XPHY_EDGE_ROW_60_Right_60 VGND VGND VPWR VPWR sky130_fd_sc_hd__decap_3
XFILLER_35_233 VGND VGND VPWR VPWR sky130_fd_sc_hd__decap_3
XFILLER_63_542 VGND VGND VPWR VPWR sky130_fd_sc_hd__decap_3
XFILLER_63_553 VGND VGND VPWR VPWR sky130_fd_sc_hd__decap_3
XFILLER_63_564 VGND VGND VPWR VPWR sky130_fd_sc_hd__decap_3
X_6820_ _6958_/CLK _6820_/D VGND VGND VPWR VPWR _6820_/Q sky130_fd_sc_hd__dfxtp_2
XTAP_TAPCELL_ROW_18_442 VGND VPWR sky130_fd_sc_hd__tapvpwrvgnd_1
XTAP_TAPCELL_ROW_46_762 VGND VPWR sky130_fd_sc_hd__tapvpwrvgnd_1
XPHY_EDGE_ROW_35_Left_144 VGND VGND VPWR VPWR sky130_fd_sc_hd__decap_3
XFILLER_16_480 VGND VGND VPWR VPWR sky130_fd_sc_hd__decap_3
XFILLER_35_299 VGND VGND VPWR VPWR sky130_fd_sc_hd__fill_1
XFILLER_50_225 VGND VGND VPWR VPWR sky130_fd_sc_hd__fill_1
XFILLER_50_236 VGND VGND VPWR VPWR sky130_fd_sc_hd__decap_3
X_6751_ _6958_/CLK _6751_/D VGND VGND VPWR VPWR _6751_/Q sky130_fd_sc_hd__dfxtp_2
X_6682_ _6684_/A VGND VGND VPWR VPWR _6682_/Y sky130_fd_sc_hd__inv_2
X_3894_ _3728_/Y _3891_/X _3893_/X _3733_/X VGND VGND VPWR VPWR _3894_/X sky130_fd_sc_hd__a22o_2
X_5633_ _5633_/A _5633_/B VGND VGND VPWR VPWR _7012_/D sky130_fd_sc_hd__nor2_2
X_5564_ hold953/X _4909_/A _4751_/B VGND VGND VPWR VPWR _7052_/D sky130_fd_sc_hd__a21bo_2
X_7303_ _7373_/CLK _7303_/D _6583_/Y VGND VGND VPWR VPWR _7303_/Q sky130_fd_sc_hd__dfrtp_2
X_4515_ _4515_/A0 _7290_/Q _4520_/S VGND VGND VPWR VPWR _7322_/D sky130_fd_sc_hd__mux2_2
XPHY_EDGE_ROW_44_Left_153 VGND VGND VPWR VPWR sky130_fd_sc_hd__decap_3
XPHY_EDGE_ROW_103_Right_103 VGND VGND VPWR VPWR sky130_fd_sc_hd__decap_3
X_7234_ _7362_/CLK _7234_/D _6514_/Y VGND VGND VPWR VPWR _7234_/Q sky130_fd_sc_hd__dfrtp_2
X_4446_ _4446_/A _4814_/B VGND VGND VPWR VPWR _4447_/B sky130_fd_sc_hd__nor2_2
XFILLER_104_249 VGND VGND VPWR VPWR sky130_fd_sc_hd__decap_3
X_7165_ _7280_/CLK _7165_/D _6445_/Y VGND VGND VPWR VPWR _7165_/Q sky130_fd_sc_hd__dfrtp_2
X_4377_ _4620_/C _4375_/X _4376_/X VGND VGND VPWR VPWR _4377_/Y sky130_fd_sc_hd__o21ai_2
XFILLER_100_400 VGND VGND VPWR VPWR sky130_fd_sc_hd__decap_3
X_3328_ _3328_/A _3328_/B VGND VGND VPWR VPWR _3340_/C sky130_fd_sc_hd__nor2_2
XFILLER_98_461 VGND VGND VPWR VPWR sky130_fd_sc_hd__decap_3
XFILLER_58_358 VGND VGND VPWR VPWR sky130_fd_sc_hd__decap_3
XFILLER_85_111 VGND VGND VPWR VPWR sky130_fd_sc_hd__fill_1
XFILLER_85_133 VGND VGND VPWR VPWR sky130_fd_sc_hd__decap_3
XFILLER_86_645 VGND VGND VPWR VPWR sky130_fd_sc_hd__decap_3
X_7096_ _7356_/CLK _7096_/D _6376_/Y VGND VGND VPWR VPWR _7096_/Q sky130_fd_sc_hd__dfrtp_2
XFILLER_98_494 VGND VGND VPWR VPWR sky130_fd_sc_hd__decap_3
XFILLER_73_317 VGND VGND VPWR VPWR sky130_fd_sc_hd__decap_3
XFILLER_85_166 VGND VGND VPWR VPWR sky130_fd_sc_hd__fill_2
XFILLER_26_200 VGND VGND VPWR VPWR sky130_fd_sc_hd__decap_3
XFILLER_54_531 VGND VGND VPWR VPWR sky130_fd_sc_hd__fill_1
XPHY_EDGE_ROW_53_Left_162 VGND VGND VPWR VPWR sky130_fd_sc_hd__decap_3
XFILLER_26_233 VGND VGND VPWR VPWR sky130_fd_sc_hd__decap_3
XFILLER_14_439 VGND VGND VPWR VPWR sky130_fd_sc_hd__fill_1
XFILLER_41_225 VGND VGND VPWR VPWR sky130_fd_sc_hd__decap_3
X_6949_ clkload6/A _6949_/D VGND VGND VPWR VPWR _6949_/Q sky130_fd_sc_hd__dfxtp_2
XFILLER_10_601 VGND VGND VPWR VPWR sky130_fd_sc_hd__decap_3
XFILLER_41_269 VGND VGND VPWR VPWR sky130_fd_sc_hd__decap_3
XFILLER_10_634 VGND VGND VPWR VPWR sky130_fd_sc_hd__decap_3
XFILLER_10_645 VGND VGND VPWR VPWR sky130_fd_sc_hd__decap_3
XFILLER_22_494 VGND VGND VPWR VPWR sky130_fd_sc_hd__decap_3
XFILLER_6_616 VGND VGND VPWR VPWR sky130_fd_sc_hd__decap_3
XFILLER_5_137 VGND VGND VPWR VPWR sky130_fd_sc_hd__decap_3
XPHY_EDGE_ROW_62_Left_171 VGND VGND VPWR VPWR sky130_fd_sc_hd__decap_3
Xhold690 _6841_/Q VGND VGND VPWR VPWR _6841_/D sky130_fd_sc_hd__dlygate4sd3_1
XFILLER_1_376 VGND VGND VPWR VPWR sky130_fd_sc_hd__decap_3
XFILLER_76_100 VGND VGND VPWR VPWR sky130_fd_sc_hd__decap_3
XFILLER_78_77 VGND VGND VPWR VPWR sky130_fd_sc_hd__decap_3
XFILLER_78_88 VGND VGND VPWR VPWR sky130_fd_sc_hd__decap_3
XFILLER_78_99 VGND VGND VPWR VPWR sky130_fd_sc_hd__decap_3
XTAP_TAPCELL_ROW_73_1071 VGND VPWR sky130_fd_sc_hd__tapvpwrvgnd_1
XFILLER_103_293 VGND VGND VPWR VPWR sky130_fd_sc_hd__decap_3
XFILLER_49_358 VGND VGND VPWR VPWR sky130_fd_sc_hd__decap_3
XFILLER_76_144 VGND VGND VPWR VPWR sky130_fd_sc_hd__decap_3
XFILLER_94_43 VGND VGND VPWR VPWR sky130_fd_sc_hd__decap_3
XPHY_EDGE_ROW_71_Left_180 VGND VGND VPWR VPWR sky130_fd_sc_hd__decap_3
XFILLER_45_520 VGND VGND VPWR VPWR sky130_fd_sc_hd__fill_1
XFILLER_64_328 VGND VGND VPWR VPWR sky130_fd_sc_hd__decap_3
XFILLER_91_136 VGND VGND VPWR VPWR sky130_fd_sc_hd__decap_3
XFILLER_17_222 VGND VGND VPWR VPWR sky130_fd_sc_hd__fill_2
XFILLER_57_391 VGND VGND VPWR VPWR sky130_fd_sc_hd__fill_1
XFILLER_91_169 VGND VGND VPWR VPWR sky130_fd_sc_hd__decap_3
XFILLER_32_203 VGND VGND VPWR VPWR sky130_fd_sc_hd__decap_3
XFILLER_60_512 VGND VGND VPWR VPWR sky130_fd_sc_hd__fill_1
XFILLER_32_236 VGND VGND VPWR VPWR sky130_fd_sc_hd__decap_3
XTAP_TAPCELL_ROW_43_732 VGND VPWR sky130_fd_sc_hd__tapvpwrvgnd_1
XTAP_TAPCELL_ROW_15_412 VGND VPWR sky130_fd_sc_hd__tapvpwrvgnd_1
XFILLER_60_589 VGND VGND VPWR VPWR sky130_fd_sc_hd__decap_3
XFILLER_9_443 VGND VGND VPWR VPWR sky130_fd_sc_hd__decap_3
XFILLER_9_465 VGND VGND VPWR VPWR sky130_fd_sc_hd__decap_3
X_5280_ _5280_/A0 _5121_/X _5292_/S VGND VGND VPWR VPWR _7190_/D sky130_fd_sc_hd__mux2_2
X_4300_ _7288_/Q _4534_/S VGND VGND VPWR VPWR _4300_/X sky130_fd_sc_hd__and2_2
XFILLER_99_225 VGND VGND VPWR VPWR sky130_fd_sc_hd__decap_3
XFILLER_99_203 VGND VGND VPWR VPWR sky130_fd_sc_hd__decap_3
XFILLER_4_192 VGND VGND VPWR VPWR sky130_fd_sc_hd__decap_3
X_4231_ _7040_/Q _3488_/B _4354_/B1 _7387_/Q _4230_/X VGND VGND VPWR VPWR _4231_/X
+ sky130_fd_sc_hd__a221o_2
XFILLER_4_85 VGND VGND VPWR VPWR sky130_fd_sc_hd__decap_3
XFILLER_67_111 VGND VGND VPWR VPWR sky130_fd_sc_hd__fill_1
XFILLER_67_122 VGND VGND VPWR VPWR sky130_fd_sc_hd__decap_3
XFILLER_68_645 VGND VGND VPWR VPWR sky130_fd_sc_hd__decap_3
XFILLER_95_420 VGND VGND VPWR VPWR sky130_fd_sc_hd__decap_3
X_4162_ _7137_/Q _4428_/B1 _4161_/X VGND VGND VPWR VPWR _4203_/A sky130_fd_sc_hd__a21o_2
XFILLER_67_155 VGND VGND VPWR VPWR sky130_fd_sc_hd__decap_3
XFILLER_83_604 VGND VGND VPWR VPWR sky130_fd_sc_hd__decap_3
X_4093_ _4394_/A _4394_/B _4092_/X VGND VGND VPWR VPWR _4210_/B sky130_fd_sc_hd__or3b_2
XFILLER_36_520 VGND VGND VPWR VPWR sky130_fd_sc_hd__decap_3
XFILLER_36_542 VGND VGND VPWR VPWR sky130_fd_sc_hd__fill_1
XFILLER_82_147 VGND VGND VPWR VPWR sky130_fd_sc_hd__fill_1
XFILLER_23_214 VGND VGND VPWR VPWR sky130_fd_sc_hd__fill_1
XFILLER_63_350 VGND VGND VPWR VPWR sky130_fd_sc_hd__decap_3
XFILLER_23_247 VGND VGND VPWR VPWR sky130_fd_sc_hd__decap_3
Xplace372 _5138_/S VGND VGND VPWR VPWR _5151_/A sky130_fd_sc_hd__buf_2
Xplace361 _3409_/X VGND VGND VPWR VPWR _4352_/B1 sky130_fd_sc_hd__buf_2
Xplace350 _4335_/B1 VGND VGND VPWR VPWR _4351_/A2 sky130_fd_sc_hd__buf_2
X_6803_ _6943_/CLK _6803_/D VGND VGND VPWR VPWR _6803_/Q sky130_fd_sc_hd__dfxtp_2
X_4995_ _4811_/C _4987_/Y _4993_/X _4994_/X VGND VGND VPWR VPWR _5657_/D sky130_fd_sc_hd__a211o_2
Xplace383 _5229_/C VGND VGND VPWR VPWR _4341_/B1 sky130_fd_sc_hd__buf_2
Xplace394 _5358_/S VGND VGND VPWR VPWR _5310_/S sky130_fd_sc_hd__buf_2
X_6734_ clkload8/A _6734_/D VGND VGND VPWR VPWR _6734_/Q sky130_fd_sc_hd__dfxtp_2
X_6665_ _6668_/A VGND VGND VPWR VPWR _6665_/Y sky130_fd_sc_hd__inv_2
X_3877_ _6906_/Q _3888_/A2 _3893_/B1 _6850_/Q _3876_/X VGND VGND VPWR VPWR _3877_/X
+ sky130_fd_sc_hd__a221o_2
X_6596_ _6598_/A VGND VGND VPWR VPWR _6596_/Y sky130_fd_sc_hd__inv_2
XTAP_TAPCELL_ROW_98_1358 VGND VPWR sky130_fd_sc_hd__tapvpwrvgnd_1
XFILLER_105_558 VGND VGND VPWR VPWR sky130_fd_sc_hd__fill_2
XFILLER_3_9 VGND VGND VPWR VPWR sky130_fd_sc_hd__decap_3
X_7217_ _7348_/CLK _7217_/D _6497_/Y VGND VGND VPWR VPWR _7217_/Q sky130_fd_sc_hd__dfrtp_2
X_4429_ _7303_/Q _4429_/A2 _4437_/B1 _7367_/Q _4429_/C1 VGND VGND VPWR VPWR _4429_/X
+ sky130_fd_sc_hd__a221o_2
XFILLER_59_612 VGND VGND VPWR VPWR sky130_fd_sc_hd__decap_3
XFILLER_59_623 VGND VGND VPWR VPWR sky130_fd_sc_hd__decap_3
X_7148_ _7276_/CLK _7148_/D _6428_/Y VGND VGND VPWR VPWR _7148_/Q sky130_fd_sc_hd__dfrtp_2
XFILLER_98_280 VGND VGND VPWR VPWR sky130_fd_sc_hd__decap_3
XFILLER_104_20 VGND VGND VPWR VPWR sky130_fd_sc_hd__decap_3
XFILLER_58_144 VGND VGND VPWR VPWR sky130_fd_sc_hd__decap_3
X_7079_ _7083_/CLK _7079_/D _6359_/Y VGND VGND VPWR VPWR _7079_/Q sky130_fd_sc_hd__dfrtp_2
XFILLER_46_339 VGND VGND VPWR VPWR sky130_fd_sc_hd__fill_1
XFILLER_73_125 VGND VGND VPWR VPWR sky130_fd_sc_hd__fill_1
XFILLER_27_542 VGND VGND VPWR VPWR sky130_fd_sc_hd__decap_3
XFILLER_39_391 VGND VGND VPWR VPWR sky130_fd_sc_hd__fill_1
XFILLER_64_35 VGND VGND VPWR VPWR sky130_fd_sc_hd__fill_1
XFILLER_73_158 VGND VGND VPWR VPWR sky130_fd_sc_hd__fill_2
XFILLER_14_203 VGND VGND VPWR VPWR sky130_fd_sc_hd__decap_3
XFILLER_27_564 VGND VGND VPWR VPWR sky130_fd_sc_hd__decap_3
XFILLER_64_57 VGND VGND VPWR VPWR sky130_fd_sc_hd__fill_1
XTAP_TAPCELL_ROW_107_1465 VGND VPWR sky130_fd_sc_hd__tapvpwrvgnd_1
XFILLER_14_236 VGND VGND VPWR VPWR sky130_fd_sc_hd__decap_3
XFILLER_27_597 VGND VGND VPWR VPWR sky130_fd_sc_hd__decap_3
XFILLER_54_394 VGND VGND VPWR VPWR sky130_fd_sc_hd__decap_3
XFILLER_14_258 VGND VGND VPWR VPWR sky130_fd_sc_hd__decap_3
Xfanout40 fanout48/X VGND VGND VPWR VPWR _6642_/A sky130_fd_sc_hd__buf_1
Xfanout51 _6685_/A VGND VGND VPWR VPWR _6364_/A sky130_fd_sc_hd__buf_2
Xfanout62 _6654_/A VGND VGND VPWR VPWR _6619_/A sky130_fd_sc_hd__buf_2
Xfanout73 _6685_/A VGND VGND VPWR VPWR _6278_/A sky130_fd_sc_hd__clkdlybuf4s25_1
XFILLER_22_280 VGND VGND VPWR VPWR sky130_fd_sc_hd__decap_3
XFILLER_10_486 VGND VGND VPWR VPWR sky130_fd_sc_hd__decap_3
XFILLER_6_424 VGND VGND VPWR VPWR sky130_fd_sc_hd__fill_2
XFILLER_6_435 VGND VGND VPWR VPWR sky130_fd_sc_hd__fill_1
XFILLER_108_352 VGND VGND VPWR VPWR sky130_fd_sc_hd__decap_3
XFILLER_6_457 VGND VGND VPWR VPWR sky130_fd_sc_hd__decap_3
XTAP_TAPCELL_ROW_75_1100 VGND VPWR sky130_fd_sc_hd__tapvpwrvgnd_1
XTAP_TAPCELL_ROW_20_470 VGND VPWR sky130_fd_sc_hd__tapvpwrvgnd_1
XFILLER_108_374 VGND VGND VPWR VPWR sky130_fd_sc_hd__decap_3
XFILLER_108_396 VGND VGND VPWR VPWR sky130_fd_sc_hd__decap_3
XFILLER_49_111 VGND VGND VPWR VPWR sky130_fd_sc_hd__fill_1
XFILLER_49_133 VGND VGND VPWR VPWR sky130_fd_sc_hd__decap_3
XFILLER_49_166 VGND VGND VPWR VPWR sky130_fd_sc_hd__fill_2
XFILLER_77_464 VGND VGND VPWR VPWR sky130_fd_sc_hd__decap_3
XFILLER_49_199 VGND VGND VPWR VPWR sky130_fd_sc_hd__decap_3
XFILLER_65_626 VGND VGND VPWR VPWR sky130_fd_sc_hd__decap_3
XFILLER_80_607 VGND VGND VPWR VPWR sky130_fd_sc_hd__decap_3
XFILLER_52_309 VGND VGND VPWR VPWR sky130_fd_sc_hd__decap_3
XFILLER_64_169 VGND VGND VPWR VPWR sky130_fd_sc_hd__decap_3
XFILLER_33_545 VGND VGND VPWR VPWR sky130_fd_sc_hd__decap_3
XFILLER_45_383 VGND VGND VPWR VPWR sky130_fd_sc_hd__decap_3
XFILLER_60_320 VGND VGND VPWR VPWR sky130_fd_sc_hd__fill_2
XFILLER_33_589 VGND VGND VPWR VPWR sky130_fd_sc_hd__decap_3
X_4780_ _4779_/X _4447_/B _4447_/A VGND VGND VPWR VPWR _4780_/Y sky130_fd_sc_hd__a21oi_2
X_3800_ _6861_/Q _3879_/B1 _3665_/X _6901_/Q _3799_/X VGND VGND VPWR VPWR _3800_/X
+ sky130_fd_sc_hd__a221o_2
XFILLER_20_206 VGND VGND VPWR VPWR sky130_fd_sc_hd__decap_3
XFILLER_60_386 VGND VGND VPWR VPWR sky130_fd_sc_hd__decap_3
X_3731_ _6758_/Q _3884_/B1 _3883_/B1 _6770_/Q VGND VGND VPWR VPWR _3731_/X sky130_fd_sc_hd__a22o_2
XFILLER_13_291 VGND VGND VPWR VPWR sky130_fd_sc_hd__decap_3
Xclkload10 _7398_/CLK VGND VGND VPWR VPWR clkload10/Y sky130_fd_sc_hd__clkinv_2
X_6450_ _6646_/A VGND VGND VPWR VPWR _6450_/Y sky130_fd_sc_hd__inv_2
XFILLER_9_295 VGND VGND VPWR VPWR sky130_fd_sc_hd__decap_3
XFILLER_9_284 VGND VGND VPWR VPWR sky130_fd_sc_hd__fill_1
XFILLER_9_262 VGND VGND VPWR VPWR sky130_fd_sc_hd__fill_2
Xclkload21 _7071_/CLK VGND VGND VPWR VPWR clkload21/X sky130_fd_sc_hd__clkbuf_8
Xclkload32 _7364_/CLK VGND VGND VPWR VPWR clkload32/X sky130_fd_sc_hd__clkbuf_1
X_6381_ _6601_/A VGND VGND VPWR VPWR _6381_/Y sky130_fd_sc_hd__inv_2
X_3593_ _3620_/A _4292_/B _3592_/X VGND VGND VPWR VPWR _3594_/B sky130_fd_sc_hd__a21o_2
XFILLER_5_490 VGND VGND VPWR VPWR sky130_fd_sc_hd__decap_3
XFILLER_102_517 VGND VGND VPWR VPWR sky130_fd_sc_hd__decap_3
XTAP_TAPCELL_ROW_93_1299 VGND VPWR sky130_fd_sc_hd__tapvpwrvgnd_1
XFILLER_102_539 VGND VGND VPWR VPWR sky130_fd_sc_hd__decap_3
X_7002_ _7374_/CLK _7002_/D _6282_/Y VGND VGND VPWR VPWR _7002_/Q sky130_fd_sc_hd__dfrtp_2
X_5194_ _5194_/A _5207_/B VGND VGND VPWR VPWR _7231_/D sky130_fd_sc_hd__and2_2
X_4214_ _7228_/Q _4214_/A2 _4348_/A2 _7164_/Q _4213_/X VGND VGND VPWR VPWR _4214_/X
+ sky130_fd_sc_hd__a221o_2
XFILLER_56_615 VGND VGND VPWR VPWR sky130_fd_sc_hd__decap_3
XFILLER_68_442 VGND VGND VPWR VPWR sky130_fd_sc_hd__decap_3
X_4145_ _7298_/Q _4244_/B _4144_/X _4347_/C1 VGND VGND VPWR VPWR _4145_/X sky130_fd_sc_hd__a211o_2
XFILLER_28_339 VGND VGND VPWR VPWR sky130_fd_sc_hd__decap_3
X_4076_ _7147_/Q _4434_/B1 _4416_/B1 _7179_/Q VGND VGND VPWR VPWR _4076_/X sky130_fd_sc_hd__a22o_2
XFILLER_24_501 VGND VGND VPWR VPWR sky130_fd_sc_hd__decap_3
XFILLER_55_169 VGND VGND VPWR VPWR sky130_fd_sc_hd__decap_3
XFILLER_71_629 VGND VGND VPWR VPWR sky130_fd_sc_hd__decap_3
XFILLER_36_383 VGND VGND VPWR VPWR sky130_fd_sc_hd__fill_1
XFILLER_63_191 VGND VGND VPWR VPWR sky130_fd_sc_hd__decap_3
XFILLER_70_139 VGND VGND VPWR VPWR sky130_fd_sc_hd__fill_1
XTAP_TAPCELL_ROW_26_529 VGND VPWR sky130_fd_sc_hd__tapvpwrvgnd_1
XFILLER_34_49 VGND VGND VPWR VPWR sky130_fd_sc_hd__decap_3
XFILLER_11_239 VGND VGND VPWR VPWR sky130_fd_sc_hd__decap_3
XFILLER_24_589 VGND VGND VPWR VPWR sky130_fd_sc_hd__fill_1
XFILLER_51_386 VGND VGND VPWR VPWR sky130_fd_sc_hd__decap_3
X_4978_ _5092_/C _4973_/X _4975_/Y _6993_/D _5666_/A VGND VGND VPWR VPWR _4978_/X
+ sky130_fd_sc_hd__a32o_2
Xclkload4 clkload4/A VGND VGND VPWR VPWR clkload4/X sky130_fd_sc_hd__clkbuf_8
X_6717_ _6943_/CLK _6717_/D VGND VGND VPWR VPWR _6717_/Q sky130_fd_sc_hd__dfxtp_2
X_6648_ _6648_/A VGND VGND VPWR VPWR _6648_/Y sky130_fd_sc_hd__inv_2
XFILLER_105_311 VGND VGND VPWR VPWR sky130_fd_sc_hd__decap_3
X_6579_ _6611_/A VGND VGND VPWR VPWR _6579_/Y sky130_fd_sc_hd__inv_2
XFILLER_3_449 VGND VGND VPWR VPWR sky130_fd_sc_hd__decap_3
XFILLER_59_57 VGND VGND VPWR VPWR sky130_fd_sc_hd__fill_1
XFILLER_59_68 VGND VGND VPWR VPWR sky130_fd_sc_hd__decap_3
XFILLER_78_206 VGND VGND VPWR VPWR sky130_fd_sc_hd__decap_3
XFILLER_105_399 VGND VGND VPWR VPWR sky130_fd_sc_hd__decap_3
XFILLER_78_239 VGND VGND VPWR VPWR sky130_fd_sc_hd__decap_3
XTAP_TAPCELL_ROW_70_1041 VGND VPWR sky130_fd_sc_hd__tapvpwrvgnd_1
XFILLER_101_583 VGND VGND VPWR VPWR sky130_fd_sc_hd__decap_3
XFILLER_19_306 VGND VGND VPWR VPWR sky130_fd_sc_hd__decap_3
XFILLER_19_328 VGND VGND VPWR VPWR sky130_fd_sc_hd__decap_3
XFILLER_46_103 VGND VGND VPWR VPWR sky130_fd_sc_hd__fill_1
XFILLER_47_626 VGND VGND VPWR VPWR sky130_fd_sc_hd__decap_3
XFILLER_86_283 VGND VGND VPWR VPWR sky130_fd_sc_hd__decap_3
XTAP_TAPCELL_ROW_6_298 VGND VPWR sky130_fd_sc_hd__tapvpwrvgnd_1
XFILLER_46_136 VGND VGND VPWR VPWR sky130_fd_sc_hd__decap_3
XFILLER_15_501 VGND VGND VPWR VPWR sky130_fd_sc_hd__decap_3
XFILLER_34_309 VGND VGND VPWR VPWR sky130_fd_sc_hd__decap_3
XFILLER_61_106 VGND VGND VPWR VPWR sky130_fd_sc_hd__decap_3
XFILLER_62_618 VGND VGND VPWR VPWR sky130_fd_sc_hd__decap_3
XFILLER_27_372 VGND VGND VPWR VPWR sky130_fd_sc_hd__decap_3
XFILLER_54_180 VGND VGND VPWR VPWR sky130_fd_sc_hd__decap_3
XFILLER_70_640 VGND VGND VPWR VPWR sky130_fd_sc_hd__decap_3
XFILLER_91_11 VGND VGND VPWR VPWR sky130_fd_sc_hd__fill_1
XFILLER_15_567 VGND VGND VPWR VPWR sky130_fd_sc_hd__decap_3
XFILLER_42_342 VGND VGND VPWR VPWR sky130_fd_sc_hd__fill_1
XFILLER_30_515 VGND VGND VPWR VPWR sky130_fd_sc_hd__decap_3
XTAP_TAPCELL_ROW_81_1170 VGND VPWR sky130_fd_sc_hd__tapvpwrvgnd_1
XFILLER_10_250 VGND VGND VPWR VPWR sky130_fd_sc_hd__fill_2
XFILLER_10_283 VGND VGND VPWR VPWR sky130_fd_sc_hd__fill_2
XFILLER_6_265 VGND VGND VPWR VPWR sky130_fd_sc_hd__decap_3
XFILLER_69_239 VGND VGND VPWR VPWR sky130_fd_sc_hd__decap_3
XFILLER_38_615 VGND VGND VPWR VPWR sky130_fd_sc_hd__decap_3
XFILLER_77_261 VGND VGND VPWR VPWR sky130_fd_sc_hd__decap_3
XFILLER_37_125 VGND VGND VPWR VPWR sky130_fd_sc_hd__decap_3
XFILLER_92_231 VGND VGND VPWR VPWR sky130_fd_sc_hd__decap_3
XFILLER_53_629 VGND VGND VPWR VPWR sky130_fd_sc_hd__decap_3
XFILLER_80_404 VGND VGND VPWR VPWR sky130_fd_sc_hd__decap_3
XFILLER_80_415 VGND VGND VPWR VPWR sky130_fd_sc_hd__decap_3
XFILLER_92_253 VGND VGND VPWR VPWR sky130_fd_sc_hd__fill_1
XPHY_EDGE_ROW_9_Left_118 VGND VGND VPWR VPWR sky130_fd_sc_hd__decap_3
XFILLER_52_139 VGND VGND VPWR VPWR sky130_fd_sc_hd__fill_1
XFILLER_80_448 VGND VGND VPWR VPWR sky130_fd_sc_hd__decap_3
X_4901_ _4901_/A0 _4899_/X _4998_/S VGND VGND VPWR VPWR _7268_/D sky130_fd_sc_hd__mux2_2
XFILLER_45_191 VGND VGND VPWR VPWR sky130_fd_sc_hd__decap_3
XTAP_TAPCELL_ROW_51_819 VGND VPWR sky130_fd_sc_hd__tapvpwrvgnd_1
XFILLER_21_526 VGND VGND VPWR VPWR sky130_fd_sc_hd__fill_2
X_4832_ _4832_/A _5657_/A VGND VGND VPWR VPWR _4832_/X sky130_fd_sc_hd__or2_2
XFILLER_60_194 VGND VGND VPWR VPWR sky130_fd_sc_hd__fill_2
X_4763_ _4762_/A _4762_/B _4948_/A VGND VGND VPWR VPWR _4763_/X sky130_fd_sc_hd__a21o_2
X_6502_ _6566_/A VGND VGND VPWR VPWR _6502_/Y sky130_fd_sc_hd__inv_2
X_4694_ _7008_/Q _4728_/A VGND VGND VPWR VPWR _4694_/Y sky130_fd_sc_hd__nor2_2
X_3714_ _3735_/A _3741_/B _3746_/C VGND VGND VPWR VPWR _3714_/X sky130_fd_sc_hd__and3_2
X_6433_ _6632_/A VGND VGND VPWR VPWR _6433_/Y sky130_fd_sc_hd__inv_2
XTAP_TAPCELL_ROW_31_587 VGND VPWR sky130_fd_sc_hd__tapvpwrvgnd_1
XFILLER_20_29 VGND VGND VPWR VPWR sky130_fd_sc_hd__decap_3
X_3645_ _3645_/A1 _3857_/A2 _4664_/B VGND VGND VPWR VPWR _7406_/D sky130_fd_sc_hd__a21o_2
XTAP_TAPCELL_ROW_95_1328 VGND VPWR sky130_fd_sc_hd__tapvpwrvgnd_1
X_6364_ _6364_/A VGND VGND VPWR VPWR _6364_/Y sky130_fd_sc_hd__inv_2
X_3576_ _7252_/Q _4599_/S _3377_/X _7220_/Q _3575_/X VGND VGND VPWR VPWR _3576_/Y
+ sky130_fd_sc_hd__a221oi_2
XFILLER_0_419 VGND VGND VPWR VPWR sky130_fd_sc_hd__fill_1
XFILLER_88_515 VGND VGND VPWR VPWR sky130_fd_sc_hd__decap_3
X_6295_ _6632_/A VGND VGND VPWR VPWR _6295_/Y sky130_fd_sc_hd__inv_2
X_5315_ _5315_/A0 _4878_/X _5333_/S VGND VGND VPWR VPWR _7173_/D sky130_fd_sc_hd__mux2_2
XFILLER_88_548 VGND VGND VPWR VPWR sky130_fd_sc_hd__fill_2
XTAP_TAPCELL_ROW_59_908 VGND VPWR sky130_fd_sc_hd__tapvpwrvgnd_1
XPHY_EDGE_ROW_89_Right_89 VGND VGND VPWR VPWR sky130_fd_sc_hd__decap_3
XFILLER_29_626 VGND VGND VPWR VPWR sky130_fd_sc_hd__decap_3
XFILLER_68_250 VGND VGND VPWR VPWR sky130_fd_sc_hd__fill_2
X_5177_ _5177_/A _5186_/B VGND VGND VPWR VPWR _7239_/D sky130_fd_sc_hd__and2_2
XFILLER_28_136 VGND VGND VPWR VPWR sky130_fd_sc_hd__decap_3
XFILLER_28_147 VGND VGND VPWR VPWR sky130_fd_sc_hd__decap_3
XFILLER_83_220 VGND VGND VPWR VPWR sky130_fd_sc_hd__decap_3
XFILLER_83_231 VGND VGND VPWR VPWR sky130_fd_sc_hd__decap_3
X_4128_ _7331_/Q _3956_/S _4428_/B1 _7139_/Q VGND VGND VPWR VPWR _4128_/X sky130_fd_sc_hd__a22o_2
XTAP_TAPCELL_ROW_3_268 VGND VPWR sky130_fd_sc_hd__tapvpwrvgnd_1
XFILLER_16_309 VGND VGND VPWR VPWR sky130_fd_sc_hd__decap_3
XFILLER_45_15 VGND VGND VPWR VPWR sky130_fd_sc_hd__decap_3
XFILLER_45_26 VGND VGND VPWR VPWR sky130_fd_sc_hd__decap_3
XFILLER_71_404 VGND VGND VPWR VPWR sky130_fd_sc_hd__fill_1
X_4059_ _7276_/Q _4437_/A2 _4056_/X _4058_/X VGND VGND VPWR VPWR _4059_/X sky130_fd_sc_hd__a211o_2
XTAP_TAPCELL_ROW_39_687 VGND VPWR sky130_fd_sc_hd__tapvpwrvgnd_1
XFILLER_36_180 VGND VGND VPWR VPWR sky130_fd_sc_hd__decap_3
XFILLER_101_21 VGND VGND VPWR VPWR sky130_fd_sc_hd__decap_3
XTAP_TAPCELL_ROW_104_1435 VGND VPWR sky130_fd_sc_hd__tapvpwrvgnd_1
XFILLER_24_375 VGND VGND VPWR VPWR sky130_fd_sc_hd__decap_3
XFILLER_51_161 VGND VGND VPWR VPWR sky130_fd_sc_hd__fill_2
XFILLER_51_172 VGND VGND VPWR VPWR sky130_fd_sc_hd__decap_3
XPHY_EDGE_ROW_98_Right_98 VGND VGND VPWR VPWR sky130_fd_sc_hd__decap_3
XFILLER_51_194 VGND VGND VPWR VPWR sky130_fd_sc_hd__decap_3
XFILLER_61_69 VGND VGND VPWR VPWR sky130_fd_sc_hd__fill_1
XFILLER_20_592 VGND VGND VPWR VPWR sky130_fd_sc_hd__decap_3
XFILLER_106_631 VGND VGND VPWR VPWR sky130_fd_sc_hd__decap_3
XFILLER_3_213 VGND VGND VPWR VPWR sky130_fd_sc_hd__decap_3
XFILLER_105_130 VGND VGND VPWR VPWR sky130_fd_sc_hd__fill_1
XFILLER_3_246 VGND VGND VPWR VPWR sky130_fd_sc_hd__decap_3
XFILLER_3_268 VGND VGND VPWR VPWR sky130_fd_sc_hd__fill_1
XFILLER_105_163 VGND VGND VPWR VPWR sky130_fd_sc_hd__decap_3
XFILLER_79_526 VGND VGND VPWR VPWR sky130_fd_sc_hd__decap_3
XFILLER_79_559 VGND VGND VPWR VPWR sky130_fd_sc_hd__fill_1
XFILLER_66_209 VGND VGND VPWR VPWR sky130_fd_sc_hd__decap_3
XFILLER_59_272 VGND VGND VPWR VPWR sky130_fd_sc_hd__fill_1
XFILLER_86_66 VGND VGND VPWR VPWR sky130_fd_sc_hd__decap_3
XFILLER_47_445 VGND VGND VPWR VPWR sky130_fd_sc_hd__decap_3
XFILLER_59_294 VGND VGND VPWR VPWR sky130_fd_sc_hd__decap_3
XFILLER_19_158 VGND VGND VPWR VPWR sky130_fd_sc_hd__decap_3
XFILLER_19_169 VGND VGND VPWR VPWR sky130_fd_sc_hd__decap_3
XFILLER_35_629 VGND VGND VPWR VPWR sky130_fd_sc_hd__decap_3
XFILLER_47_489 VGND VGND VPWR VPWR sky130_fd_sc_hd__decap_3
XFILLER_74_253 VGND VGND VPWR VPWR sky130_fd_sc_hd__fill_1
XFILLER_27_180 VGND VGND VPWR VPWR sky130_fd_sc_hd__decap_3
XFILLER_74_297 VGND VGND VPWR VPWR sky130_fd_sc_hd__decap_3
XFILLER_27_191 VGND VGND VPWR VPWR sky130_fd_sc_hd__decap_3
XFILLER_15_375 VGND VGND VPWR VPWR sky130_fd_sc_hd__decap_3
XFILLER_42_194 VGND VGND VPWR VPWR sky130_fd_sc_hd__fill_2
XFILLER_11_570 VGND VGND VPWR VPWR sky130_fd_sc_hd__decap_3
XFILLER_51_80 VGND VGND VPWR VPWR sky130_fd_sc_hd__decap_3
XFILLER_7_585 VGND VGND VPWR VPWR sky130_fd_sc_hd__decap_3
X_3361_ _3561_/A _3386_/B VGND VGND VPWR VPWR _3376_/B sky130_fd_sc_hd__and2_2
X_5100_ _5100_/A _5100_/B VGND VGND VPWR VPWR _5100_/Y sky130_fd_sc_hd__xnor2_2
XFILLER_97_323 VGND VGND VPWR VPWR sky130_fd_sc_hd__decap_3
XFILLER_2_290 VGND VGND VPWR VPWR sky130_fd_sc_hd__decap_3
X_5031_ _5032_/A _5031_/B VGND VGND VPWR VPWR _5031_/X sky130_fd_sc_hd__xor2_2
XTAP_TAPCELL_ROW_90_1269 VGND VPWR sky130_fd_sc_hd__tapvpwrvgnd_1
XFILLER_85_529 VGND VGND VPWR VPWR sky130_fd_sc_hd__decap_3
Xhold1208 _7299_/Q VGND VGND VPWR VPWR _4563_/A sky130_fd_sc_hd__dlygate4sd3_1
Xhold1219 _7287_/Q VGND VGND VPWR VPWR _4587_/A sky130_fd_sc_hd__dlygate4sd3_1
XFILLER_97_389 VGND VGND VPWR VPWR sky130_fd_sc_hd__decap_3
XFILLER_97_378 VGND VGND VPWR VPWR sky130_fd_sc_hd__decap_3
XFILLER_65_220 VGND VGND VPWR VPWR sky130_fd_sc_hd__decap_3
XFILLER_26_629 VGND VGND VPWR VPWR sky130_fd_sc_hd__decap_3
XFILLER_65_275 VGND VGND VPWR VPWR sky130_fd_sc_hd__decap_3
XTAP_TAPCELL_ROW_0_227 VGND VPWR sky130_fd_sc_hd__tapvpwrvgnd_1
XFILLER_80_212 VGND VGND VPWR VPWR sky130_fd_sc_hd__decap_3
XFILLER_93_595 VGND VGND VPWR VPWR sky130_fd_sc_hd__decap_3
X_6982_ _7382_/CLK _6982_/D _6262_/Y VGND VGND VPWR VPWR _6982_/Q sky130_fd_sc_hd__dfrtp_2
XTAP_TAPCELL_ROW_0_238 VGND VPWR sky130_fd_sc_hd__tapvpwrvgnd_1
XFILLER_18_180 VGND VGND VPWR VPWR sky130_fd_sc_hd__decap_3
XFILLER_80_256 VGND VGND VPWR VPWR sky130_fd_sc_hd__decap_3
XTAP_TAPCELL_ROW_64_966 VGND VPWR sky130_fd_sc_hd__tapvpwrvgnd_1
XTAP_TAPCELL_ROW_36_646 VGND VPWR sky130_fd_sc_hd__tapvpwrvgnd_1
XFILLER_33_172 VGND VGND VPWR VPWR sky130_fd_sc_hd__decap_3
XFILLER_21_323 VGND VGND VPWR VPWR sky130_fd_sc_hd__decap_3
X_4815_ _4812_/Y _4813_/Y _4814_/Y _4779_/X VGND VGND VPWR VPWR _4815_/X sky130_fd_sc_hd__o211a_2
X_4746_ _4764_/B _4069_/B _4744_/Y _4745_/Y _4852_/A VGND VGND VPWR VPWR _4746_/X
+ sky130_fd_sc_hd__o32a_2
X_4677_ _6989_/Q _4677_/B VGND VGND VPWR VPWR _5036_/A sky130_fd_sc_hd__and2_2
XFILLER_103_9 VGND VGND VPWR VPWR sky130_fd_sc_hd__decap_3
X_7396_ _7397_/CLK _7396_/D _6676_/Y VGND VGND VPWR VPWR _7396_/Q sky130_fd_sc_hd__dfrtp_2
X_6416_ _6541_/A VGND VGND VPWR VPWR _6416_/Y sky130_fd_sc_hd__inv_2
X_6347_ _6536_/A VGND VGND VPWR VPWR _6347_/Y sky130_fd_sc_hd__inv_2
XTAP_TAPCELL_ROW_8_327 VGND VPWR sky130_fd_sc_hd__tapvpwrvgnd_1
XFILLER_103_623 VGND VGND VPWR VPWR sky130_fd_sc_hd__decap_3
X_3559_ _3553_/X _3557_/X _3558_/X _3429_/X VGND VGND VPWR VPWR _4295_/B sky130_fd_sc_hd__o211a_2
XFILLER_102_144 VGND VGND VPWR VPWR sky130_fd_sc_hd__decap_3
XFILLER_76_507 VGND VGND VPWR VPWR sky130_fd_sc_hd__decap_3
XFILLER_88_345 VGND VGND VPWR VPWR sky130_fd_sc_hd__decap_3
X_6278_ _6278_/A VGND VGND VPWR VPWR _6278_/Y sky130_fd_sc_hd__inv_2
XFILLER_102_177 VGND VGND VPWR VPWR sky130_fd_sc_hd__decap_3
XFILLER_48_209 VGND VGND VPWR VPWR sky130_fd_sc_hd__decap_3
XFILLER_88_378 VGND VGND VPWR VPWR sky130_fd_sc_hd__decap_3
X_5229_ _5362_/C _5229_/B _5229_/C VGND VGND VPWR VPWR _5292_/S sky130_fd_sc_hd__and3b_2
XFILLER_56_220 VGND VGND VPWR VPWR sky130_fd_sc_hd__decap_3
XFILLER_17_629 VGND VGND VPWR VPWR sky130_fd_sc_hd__decap_3
XFILLER_56_253 VGND VGND VPWR VPWR sky130_fd_sc_hd__decap_3
XFILLER_16_139 VGND VGND VPWR VPWR sky130_fd_sc_hd__fill_1
XFILLER_71_234 VGND VGND VPWR VPWR sky130_fd_sc_hd__decap_3
XFILLER_71_256 VGND VGND VPWR VPWR sky130_fd_sc_hd__decap_3
XFILLER_40_621 VGND VGND VPWR VPWR sky130_fd_sc_hd__decap_3
XFILLER_12_345 VGND VGND VPWR VPWR sky130_fd_sc_hd__decap_3
XFILLER_12_378 VGND VGND VPWR VPWR sky130_fd_sc_hd__decap_3
XFILLER_8_327 VGND VGND VPWR VPWR sky130_fd_sc_hd__decap_3
XFILLER_4_500 VGND VGND VPWR VPWR sky130_fd_sc_hd__decap_3
XFILLER_4_533 VGND VGND VPWR VPWR sky130_fd_sc_hd__decap_3
XFILLER_4_566 VGND VGND VPWR VPWR sky130_fd_sc_hd__decap_3
XFILLER_79_334 VGND VGND VPWR VPWR sky130_fd_sc_hd__fill_2
XFILLER_75_540 VGND VGND VPWR VPWR sky130_fd_sc_hd__decap_3
XFILLER_94_348 VGND VGND VPWR VPWR sky130_fd_sc_hd__decap_3
XFILLER_35_415 VGND VGND VPWR VPWR sky130_fd_sc_hd__decap_3
XFILLER_47_275 VGND VGND VPWR VPWR sky130_fd_sc_hd__decap_3
XFILLER_62_212 VGND VGND VPWR VPWR sky130_fd_sc_hd__fill_2
XFILLER_16_640 VGND VGND VPWR VPWR sky130_fd_sc_hd__decap_3
XFILLER_15_150 VGND VGND VPWR VPWR sky130_fd_sc_hd__decap_3
XFILLER_15_161 VGND VGND VPWR VPWR sky130_fd_sc_hd__decap_3
XFILLER_31_610 VGND VGND VPWR VPWR sky130_fd_sc_hd__decap_3
XFILLER_43_470 VGND VGND VPWR VPWR sky130_fd_sc_hd__decap_3
XFILLER_50_429 VGND VGND VPWR VPWR sky130_fd_sc_hd__decap_3
XFILLER_90_598 VGND VGND VPWR VPWR sky130_fd_sc_hd__decap_3
XTAP_TAPCELL_ROW_61_936 VGND VPWR sky130_fd_sc_hd__tapvpwrvgnd_1
XTAP_TAPCELL_ROW_33_616 VGND VPWR sky130_fd_sc_hd__tapvpwrvgnd_1
XFILLER_15_172 VGND VGND VPWR VPWR sky130_fd_sc_hd__decap_3
XFILLER_31_632 VGND VGND VPWR VPWR sky130_fd_sc_hd__decap_3
XFILLER_43_481 VGND VGND VPWR VPWR sky130_fd_sc_hd__decap_3
XPHY_EDGE_ROW_99_Left_208 VGND VGND VPWR VPWR sky130_fd_sc_hd__decap_3
XFILLER_30_197 VGND VGND VPWR VPWR sky130_fd_sc_hd__decap_3
XTAP_TAPCELL_ROW_13_384 VGND VPWR sky130_fd_sc_hd__tapvpwrvgnd_1
XFILLER_7_371 VGND VGND VPWR VPWR sky130_fd_sc_hd__fill_1
XFILLER_7_74 VGND VGND VPWR VPWR sky130_fd_sc_hd__decap_3
X_7250_ _7355_/CLK _7250_/D _6530_/Y VGND VGND VPWR VPWR _7250_/Q sky130_fd_sc_hd__dfrtp_2
X_4462_ _3621_/B _3618_/X _3541_/X VGND VGND VPWR VPWR _4462_/Y sky130_fd_sc_hd__o21ai_2
X_3413_ _7155_/Q _3409_/X _3410_/X _3412_/X VGND VGND VPWR VPWR _3413_/X sky130_fd_sc_hd__a211o_2
X_7181_ _7363_/CLK _7181_/D _6461_/Y VGND VGND VPWR VPWR _7181_/Q sky130_fd_sc_hd__dfrtp_2
X_4393_ _7305_/Q _4998_/S _4434_/A2 _7113_/Q _4392_/X VGND VGND VPWR VPWR _4393_/X
+ sky130_fd_sc_hd__a221o_2
X_3344_ _3519_/B _5118_/D VGND VGND VPWR VPWR _3344_/Y sky130_fd_sc_hd__nor2_2
XFILLER_98_643 VGND VGND VPWR VPWR sky130_fd_sc_hd__fill_1
XFILLER_97_131 VGND VGND VPWR VPWR sky130_fd_sc_hd__fill_2
Xhold1005 _7258_/Q VGND VGND VPWR VPWR _5063_/A0 sky130_fd_sc_hd__dlygate4sd3_1
XFILLER_97_164 VGND VGND VPWR VPWR sky130_fd_sc_hd__decap_3
XFILLER_85_337 VGND VGND VPWR VPWR sky130_fd_sc_hd__fill_2
Xhold1016 _7275_/Q VGND VGND VPWR VPWR _4772_/A0 sky130_fd_sc_hd__dlygate4sd3_1
Xhold1027 _7242_/Q VGND VGND VPWR VPWR _5171_/A sky130_fd_sc_hd__dlygate4sd3_1
Xhold1038 _7385_/Q VGND VGND VPWR VPWR _3864_/A0 sky130_fd_sc_hd__dlygate4sd3_1
Xhold1049 _7259_/Q VGND VGND VPWR VPWR _5041_/A0 sky130_fd_sc_hd__dlygate4sd3_1
X_5014_ _6990_/Q _5014_/B VGND VGND VPWR VPWR _5015_/C sky130_fd_sc_hd__or2_2
XFILLER_38_242 VGND VGND VPWR VPWR sky130_fd_sc_hd__fill_1
XFILLER_38_253 VGND VGND VPWR VPWR sky130_fd_sc_hd__fill_1
XFILLER_66_573 VGND VGND VPWR VPWR sky130_fd_sc_hd__fill_1
XFILLER_38_286 VGND VGND VPWR VPWR sky130_fd_sc_hd__decap_3
XFILLER_53_223 VGND VGND VPWR VPWR sky130_fd_sc_hd__fill_1
XFILLER_66_595 VGND VGND VPWR VPWR sky130_fd_sc_hd__fill_2
XTAP_TAPCELL_ROW_49_793 VGND VPWR sky130_fd_sc_hd__tapvpwrvgnd_1
XFILLER_81_565 VGND VGND VPWR VPWR sky130_fd_sc_hd__decap_3
X_6965_ _6965_/CLK _6965_/D VGND VGND VPWR VPWR _6965_/Q sky130_fd_sc_hd__dfxtp_2
XFILLER_22_610 VGND VGND VPWR VPWR sky130_fd_sc_hd__decap_3
XFILLER_53_267 VGND VGND VPWR VPWR sky130_fd_sc_hd__decap_3
XFILLER_22_643 VGND VGND VPWR VPWR sky130_fd_sc_hd__fill_1
X_6896_ _6965_/CLK _6896_/D VGND VGND VPWR VPWR _6896_/Q sky130_fd_sc_hd__dfxtp_2
XFILLER_21_142 VGND VGND VPWR VPWR sky130_fd_sc_hd__decap_3
XFILLER_42_27 VGND VGND VPWR VPWR sky130_fd_sc_hd__fill_1
XFILLER_21_175 VGND VGND VPWR VPWR sky130_fd_sc_hd__decap_3
XFILLER_21_186 VGND VGND VPWR VPWR sky130_fd_sc_hd__decap_3
X_4729_ _5061_/S _4729_/B VGND VGND VPWR VPWR _4729_/Y sky130_fd_sc_hd__nand2_2
XFILLER_107_225 VGND VGND VPWR VPWR sky130_fd_sc_hd__decap_3
XFILLER_101_6 VGND VGND VPWR VPWR sky130_fd_sc_hd__decap_3
XFILLER_107_31 VGND VGND VPWR VPWR sky130_fd_sc_hd__decap_3
XFILLER_1_514 VGND VGND VPWR VPWR sky130_fd_sc_hd__decap_3
XFILLER_89_610 VGND VGND VPWR VPWR sky130_fd_sc_hd__decap_3
X_7379_ _7380_/CLK _7379_/D _6659_/Y VGND VGND VPWR VPWR _7379_/Q sky130_fd_sc_hd__dfrtp_2
Xhold850 _7069_/Q VGND VGND VPWR VPWR _7069_/D sky130_fd_sc_hd__dlygate4sd3_1
Xhold861 _7071_/Q VGND VGND VPWR VPWR _7071_/D sky130_fd_sc_hd__dlygate4sd3_1
Xhold872 _7108_/Q VGND VGND VPWR VPWR _7108_/D sky130_fd_sc_hd__dlygate4sd3_1
XFILLER_107_75 VGND VGND VPWR VPWR sky130_fd_sc_hd__decap_3
XFILLER_1_547 VGND VGND VPWR VPWR sky130_fd_sc_hd__decap_3
XFILLER_88_131 VGND VGND VPWR VPWR sky130_fd_sc_hd__decap_3
XFILLER_89_643 VGND VGND VPWR VPWR sky130_fd_sc_hd__decap_3
Xhold883 _7094_/Q VGND VGND VPWR VPWR _7094_/D sky130_fd_sc_hd__dlygate4sd3_1
Xhold894 _7081_/Q VGND VGND VPWR VPWR _7081_/D sky130_fd_sc_hd__dlygate4sd3_1
XFILLER_88_175 VGND VGND VPWR VPWR sky130_fd_sc_hd__decap_3
XFILLER_29_220 VGND VGND VPWR VPWR sky130_fd_sc_hd__decap_3
XFILLER_76_337 VGND VGND VPWR VPWR sky130_fd_sc_hd__decap_3
XFILLER_29_231 VGND VGND VPWR VPWR sky130_fd_sc_hd__decap_3
XFILLER_29_297 VGND VGND VPWR VPWR sky130_fd_sc_hd__decap_3
XFILLER_57_595 VGND VGND VPWR VPWR sky130_fd_sc_hd__decap_3
XFILLER_83_23 VGND VGND VPWR VPWR sky130_fd_sc_hd__decap_3
XTAP_TAPCELL_ROW_67_1002 VGND VPWR sky130_fd_sc_hd__tapvpwrvgnd_1
XFILLER_32_429 VGND VGND VPWR VPWR sky130_fd_sc_hd__decap_3
XFILLER_13_632 VGND VGND VPWR VPWR sky130_fd_sc_hd__decap_3
XFILLER_12_153 VGND VGND VPWR VPWR sky130_fd_sc_hd__decap_3
XFILLER_40_462 VGND VGND VPWR VPWR sky130_fd_sc_hd__fill_2
XFILLER_9_603 VGND VGND VPWR VPWR sky130_fd_sc_hd__decap_3
XFILLER_9_647 VGND VGND VPWR VPWR sky130_fd_sc_hd__fill_1
XFILLER_12_197 VGND VGND VPWR VPWR sky130_fd_sc_hd__decap_3
XTAP_TAPCELL_ROW_78_1131 VGND VPWR sky130_fd_sc_hd__tapvpwrvgnd_1
XTAP_TAPCELL_ROW_10_354 VGND VPWR sky130_fd_sc_hd__tapvpwrvgnd_1
XFILLER_4_330 VGND VGND VPWR VPWR sky130_fd_sc_hd__decap_3
XFILLER_4_374 VGND VGND VPWR VPWR sky130_fd_sc_hd__decap_3
XFILLER_79_164 VGND VGND VPWR VPWR sky130_fd_sc_hd__decap_3
XFILLER_79_175 VGND VGND VPWR VPWR sky130_fd_sc_hd__decap_3
XFILLER_95_624 VGND VGND VPWR VPWR sky130_fd_sc_hd__decap_3
XFILLER_95_613 VGND VGND VPWR VPWR sky130_fd_sc_hd__decap_3
XFILLER_82_307 VGND VGND VPWR VPWR sky130_fd_sc_hd__fill_1
XFILLER_82_318 VGND VGND VPWR VPWR sky130_fd_sc_hd__decap_3
XFILLER_94_178 VGND VGND VPWR VPWR sky130_fd_sc_hd__decap_3
XTAP_TAPCELL_ROW_89_1260 VGND VPWR sky130_fd_sc_hd__tapvpwrvgnd_1
XTAP_TAPCELL_ROW_18_443 VGND VPWR sky130_fd_sc_hd__tapvpwrvgnd_1
XFILLER_23_418 VGND VGND VPWR VPWR sky130_fd_sc_hd__decap_3
XFILLER_35_267 VGND VGND VPWR VPWR sky130_fd_sc_hd__decap_3
XFILLER_90_351 VGND VGND VPWR VPWR sky130_fd_sc_hd__decap_3
X_6750_ clkload7/A _6750_/D VGND VGND VPWR VPWR _6750_/Q sky130_fd_sc_hd__dfxtp_2
XTAP_TAPCELL_ROW_46_763 VGND VPWR sky130_fd_sc_hd__tapvpwrvgnd_1
XFILLER_50_248 VGND VGND VPWR VPWR sky130_fd_sc_hd__fill_1
X_5701_ _7356_/Q hold933/X _5721_/S VGND VGND VPWR VPWR _6700_/D sky130_fd_sc_hd__mux2_2
X_3962_ _3962_/A0 _4505_/A0 _3975_/S VGND VGND VPWR VPWR _7359_/D sky130_fd_sc_hd__mux2_2
X_6681_ _6684_/A VGND VGND VPWR VPWR _6681_/Y sky130_fd_sc_hd__inv_2
X_3893_ _6759_/Q _3926_/B1 _3893_/B1 _6753_/Q _3892_/X VGND VGND VPWR VPWR _3893_/X
+ sky130_fd_sc_hd__a221o_2
X_5632_ _5632_/A VGND VGND VPWR VPWR _5633_/A sky130_fd_sc_hd__inv_2
X_5563_ hold952/X _4909_/A _4729_/B VGND VGND VPWR VPWR _7053_/D sky130_fd_sc_hd__a21bo_2
X_7302_ _7366_/CLK _7302_/D _6582_/Y VGND VGND VPWR VPWR _7302_/Q sky130_fd_sc_hd__dfrtp_2
XFILLER_7_190 VGND VGND VPWR VPWR sky130_fd_sc_hd__decap_3
XFILLER_104_206 VGND VGND VPWR VPWR sky130_fd_sc_hd__fill_2
X_7233_ _7361_/CLK _7233_/D _6513_/Y VGND VGND VPWR VPWR _7233_/Q sky130_fd_sc_hd__dfrtp_2
X_4445_ _4813_/A _4813_/B VGND VGND VPWR VPWR _4814_/B sky130_fd_sc_hd__nor2_2
X_7164_ _7361_/CLK _7164_/D _6444_/Y VGND VGND VPWR VPWR _7164_/Q sky130_fd_sc_hd__dfrtp_2
X_4376_ _4376_/A _4376_/B _4376_/C _4273_/D VGND VGND VPWR VPWR _4376_/X sky130_fd_sc_hd__or4b_2
XFILLER_58_315 VGND VGND VPWR VPWR sky130_fd_sc_hd__decap_3
X_3327_ _6981_/Q _3327_/B VGND VGND VPWR VPWR _3328_/B sky130_fd_sc_hd__nor2_2
XFILLER_98_473 VGND VGND VPWR VPWR sky130_fd_sc_hd__decap_3
XFILLER_58_348 VGND VGND VPWR VPWR sky130_fd_sc_hd__fill_1
X_7095_ _7355_/CLK _7095_/D _6375_/Y VGND VGND VPWR VPWR _7095_/Q sky130_fd_sc_hd__dfrtp_2
XFILLER_39_551 VGND VGND VPWR VPWR sky130_fd_sc_hd__decap_3
XFILLER_85_145 VGND VGND VPWR VPWR sky130_fd_sc_hd__decap_3
XFILLER_26_212 VGND VGND VPWR VPWR sky130_fd_sc_hd__decap_3
XFILLER_73_329 VGND VGND VPWR VPWR sky130_fd_sc_hd__decap_3
XFILLER_54_554 VGND VGND VPWR VPWR sky130_fd_sc_hd__fill_1
XFILLER_26_256 VGND VGND VPWR VPWR sky130_fd_sc_hd__decap_3
XFILLER_26_278 VGND VGND VPWR VPWR sky130_fd_sc_hd__decap_3
XFILLER_41_204 VGND VGND VPWR VPWR sky130_fd_sc_hd__fill_1
XFILLER_54_576 VGND VGND VPWR VPWR sky130_fd_sc_hd__decap_3
X_6948_ _6966_/CLK _6948_/D VGND VGND VPWR VPWR _6948_/Q sky130_fd_sc_hd__dfxtp_2
XFILLER_22_462 VGND VGND VPWR VPWR sky130_fd_sc_hd__decap_3
X_6879_ _6976_/CLK _6879_/D VGND VGND VPWR VPWR _6879_/Q sky130_fd_sc_hd__dfxtp_2
XFILLER_10_613 VGND VGND VPWR VPWR sky130_fd_sc_hd__decap_3
XFILLER_5_116 VGND VGND VPWR VPWR sky130_fd_sc_hd__decap_3
XFILLER_6_628 VGND VGND VPWR VPWR sky130_fd_sc_hd__decap_3
XFILLER_108_567 VGND VGND VPWR VPWR sky130_fd_sc_hd__decap_3
XFILLER_108_589 VGND VGND VPWR VPWR sky130_fd_sc_hd__decap_3
XFILLER_1_300 VGND VGND VPWR VPWR sky130_fd_sc_hd__decap_3
Xhold680 _6788_/Q VGND VGND VPWR VPWR _6788_/D sky130_fd_sc_hd__dlygate4sd3_1
Xhold691 _6933_/Q VGND VGND VPWR VPWR _6933_/D sky130_fd_sc_hd__dlygate4sd3_1
XTAP_TAPCELL_ROW_73_1072 VGND VPWR sky130_fd_sc_hd__tapvpwrvgnd_1
XFILLER_49_337 VGND VGND VPWR VPWR sky130_fd_sc_hd__decap_3
XFILLER_76_123 VGND VGND VPWR VPWR sky130_fd_sc_hd__decap_3
XFILLER_77_635 VGND VGND VPWR VPWR sky130_fd_sc_hd__decap_3
XFILLER_17_201 VGND VGND VPWR VPWR sky130_fd_sc_hd__decap_3
XFILLER_94_66 VGND VGND VPWR VPWR sky130_fd_sc_hd__fill_1
XFILLER_17_234 VGND VGND VPWR VPWR sky130_fd_sc_hd__decap_3
XFILLER_27_60 VGND VGND VPWR VPWR sky130_fd_sc_hd__fill_2
XFILLER_45_532 VGND VGND VPWR VPWR sky130_fd_sc_hd__fill_1
XFILLER_45_554 VGND VGND VPWR VPWR sky130_fd_sc_hd__decap_3
XFILLER_91_148 VGND VGND VPWR VPWR sky130_fd_sc_hd__decap_3
XFILLER_94_99 VGND VGND VPWR VPWR sky130_fd_sc_hd__decap_3
XFILLER_17_267 VGND VGND VPWR VPWR sky130_fd_sc_hd__decap_3
XFILLER_17_278 VGND VGND VPWR VPWR sky130_fd_sc_hd__fill_2
XFILLER_27_93 VGND VGND VPWR VPWR sky130_fd_sc_hd__fill_2
XFILLER_45_576 VGND VGND VPWR VPWR sky130_fd_sc_hd__fill_2
XFILLER_17_289 VGND VGND VPWR VPWR sky130_fd_sc_hd__decap_3
XFILLER_32_215 VGND VGND VPWR VPWR sky130_fd_sc_hd__decap_3
XFILLER_32_248 VGND VGND VPWR VPWR sky130_fd_sc_hd__decap_3
XTAP_TAPCELL_ROW_43_733 VGND VPWR sky130_fd_sc_hd__tapvpwrvgnd_1
XTAP_TAPCELL_ROW_15_402 VGND VPWR sky130_fd_sc_hd__tapvpwrvgnd_1
XFILLER_13_440 VGND VGND VPWR VPWR sky130_fd_sc_hd__decap_3
XFILLER_40_270 VGND VGND VPWR VPWR sky130_fd_sc_hd__fill_1
XFILLER_9_477 VGND VGND VPWR VPWR sky130_fd_sc_hd__fill_1
X_4230_ _7227_/Q _4307_/A2 _4352_/A2 _7291_/Q _4229_/X VGND VGND VPWR VPWR _4230_/X
+ sky130_fd_sc_hd__a221o_2
XFILLER_99_248 VGND VGND VPWR VPWR sky130_fd_sc_hd__fill_1
XFILLER_101_209 VGND VGND VPWR VPWR sky130_fd_sc_hd__decap_3
X_4161_ _7265_/Q _4190_/A2 _4214_/A2 _7233_/Q _4160_/X VGND VGND VPWR VPWR _4161_/X
+ sky130_fd_sc_hd__a221o_2
XFILLER_67_167 VGND VGND VPWR VPWR sky130_fd_sc_hd__fill_1
X_4092_ _7366_/Q _4270_/B _4436_/B1 _7174_/Q _4091_/X VGND VGND VPWR VPWR _4092_/X
+ sky130_fd_sc_hd__a221o_2
XFILLER_67_178 VGND VGND VPWR VPWR sky130_fd_sc_hd__decap_3
XFILLER_48_392 VGND VGND VPWR VPWR sky130_fd_sc_hd__decap_3
XFILLER_63_340 VGND VGND VPWR VPWR sky130_fd_sc_hd__fill_1
XFILLER_82_137 VGND VGND VPWR VPWR sky130_fd_sc_hd__decap_3
XFILLER_36_587 VGND VGND VPWR VPWR sky130_fd_sc_hd__fill_1
Xplace340 _5429_/S VGND VGND VPWR VPWR _5427_/S sky130_fd_sc_hd__buf_2
X_6802_ _6943_/CLK _6802_/D VGND VGND VPWR VPWR _6802_/Q sky130_fd_sc_hd__dfxtp_2
XFILLER_90_181 VGND VGND VPWR VPWR sky130_fd_sc_hd__decap_3
Xplace373 _4832_/A VGND VGND VPWR VPWR _4799_/A sky130_fd_sc_hd__buf_2
Xplace362 _4265_/B VGND VGND VPWR VPWR _4102_/B sky130_fd_sc_hd__buf_2
Xplace351 _3417_/X VGND VGND VPWR VPWR _4335_/B1 sky130_fd_sc_hd__buf_2
X_4994_ _5006_/A1 _4994_/A2 _4987_/A _5033_/B2 VGND VGND VPWR VPWR _4994_/X sky130_fd_sc_hd__a22o_2
XFILLER_23_259 VGND VGND VPWR VPWR sky130_fd_sc_hd__decap_3
Xplace384 _3334_/Y VGND VGND VPWR VPWR _3339_/C1 sky130_fd_sc_hd__buf_2
Xplace395 _7412_/A VGND VGND VPWR VPWR _5358_/S sky130_fd_sc_hd__buf_2
X_6733_ _6958_/CLK _6733_/D VGND VGND VPWR VPWR _6733_/Q sky130_fd_sc_hd__dfxtp_2
X_3945_ _7367_/Q _4488_/A0 _3945_/S VGND VGND VPWR VPWR _7367_/D sky130_fd_sc_hd__mux2_2
X_6664_ _6667_/A VGND VGND VPWR VPWR _6664_/Y sky130_fd_sc_hd__inv_2
XFILLER_31_281 VGND VGND VPWR VPWR sky130_fd_sc_hd__decap_3
X_5615_ _5615_/A _5633_/B VGND VGND VPWR VPWR _7020_/D sky130_fd_sc_hd__or2_2
X_3876_ _6858_/Q _3889_/A2 _3665_/X _6898_/Q VGND VGND VPWR VPWR _3876_/X sky130_fd_sc_hd__a22o_2
X_6595_ _6598_/A VGND VGND VPWR VPWR _6595_/Y sky130_fd_sc_hd__inv_2
XTAP_TAPCELL_ROW_98_1359 VGND VPWR sky130_fd_sc_hd__tapvpwrvgnd_1
XFILLER_3_609 VGND VGND VPWR VPWR sky130_fd_sc_hd__decap_3
X_7216_ _7376_/CLK _7216_/D _6496_/Y VGND VGND VPWR VPWR _7216_/Q sky130_fd_sc_hd__dfrtp_2
X_4428_ _7335_/Q _3945_/S _4428_/B1 _7143_/Q VGND VGND VPWR VPWR _4428_/X sky130_fd_sc_hd__a22o_2
XFILLER_48_48 VGND VGND VPWR VPWR sky130_fd_sc_hd__fill_1
XFILLER_59_635 VGND VGND VPWR VPWR sky130_fd_sc_hd__decap_3
XFILLER_86_410 VGND VGND VPWR VPWR sky130_fd_sc_hd__decap_3
XFILLER_86_421 VGND VGND VPWR VPWR sky130_fd_sc_hd__fill_2
X_7147_ _7363_/CLK _7147_/D _6427_/Y VGND VGND VPWR VPWR _7147_/Q sky130_fd_sc_hd__dfrtp_2
X_4359_ _4367_/C _4367_/A _4367_/B VGND VGND VPWR VPWR _5071_/B sky130_fd_sc_hd__nand3b_2
XFILLER_100_220 VGND VGND VPWR VPWR sky130_fd_sc_hd__decap_3
XFILLER_58_156 VGND VGND VPWR VPWR sky130_fd_sc_hd__decap_3
XFILLER_86_454 VGND VGND VPWR VPWR sky130_fd_sc_hd__fill_1
X_7078_ _7397_/CLK _7078_/D _6358_/Y VGND VGND VPWR VPWR _7078_/Q sky130_fd_sc_hd__dfrtp_2
XFILLER_104_32 VGND VGND VPWR VPWR sky130_fd_sc_hd__decap_3
XFILLER_58_178 VGND VGND VPWR VPWR sky130_fd_sc_hd__decap_3
XFILLER_27_554 VGND VGND VPWR VPWR sky130_fd_sc_hd__decap_3
XFILLER_73_137 VGND VGND VPWR VPWR sky130_fd_sc_hd__fill_1
XFILLER_27_576 VGND VGND VPWR VPWR sky130_fd_sc_hd__decap_3
XFILLER_42_513 VGND VGND VPWR VPWR sky130_fd_sc_hd__decap_3
XFILLER_54_340 VGND VGND VPWR VPWR sky130_fd_sc_hd__fill_1
XFILLER_54_362 VGND VGND VPWR VPWR sky130_fd_sc_hd__fill_2
XFILLER_54_373 VGND VGND VPWR VPWR sky130_fd_sc_hd__decap_3
XTAP_TAPCELL_ROW_107_1466 VGND VPWR sky130_fd_sc_hd__tapvpwrvgnd_1
XFILLER_81_181 VGND VGND VPWR VPWR sky130_fd_sc_hd__decap_3
XFILLER_14_248 VGND VGND VPWR VPWR sky130_fd_sc_hd__decap_3
Xfanout30 fanout48/X VGND VGND VPWR VPWR _6559_/A sky130_fd_sc_hd__clkdlybuf4s25_1
XFILLER_10_410 VGND VGND VPWR VPWR sky130_fd_sc_hd__decap_3
XFILLER_80_57 VGND VGND VPWR VPWR sky130_fd_sc_hd__decap_3
Xfanout41 _6602_/A VGND VGND VPWR VPWR _6638_/A sky130_fd_sc_hd__buf_2
Xfanout52 fanout67/X VGND VGND VPWR VPWR _6646_/A sky130_fd_sc_hd__buf_2
Xfanout63 _6616_/A VGND VGND VPWR VPWR _6654_/A sky130_fd_sc_hd__buf_1
Xfanout74 reset VGND VGND VPWR VPWR _6685_/A sky130_fd_sc_hd__clkdlybuf4s25_1
XFILLER_10_454 VGND VGND VPWR VPWR sky130_fd_sc_hd__fill_2
XFILLER_6_414 VGND VGND VPWR VPWR sky130_fd_sc_hd__decap_3
XFILLER_13_95 VGND VGND VPWR VPWR sky130_fd_sc_hd__decap_3
XTAP_TAPCELL_ROW_75_1101 VGND VPWR sky130_fd_sc_hd__tapvpwrvgnd_1
XTAP_TAPCELL_ROW_20_460 VGND VPWR sky130_fd_sc_hd__tapvpwrvgnd_1
XFILLER_2_631 VGND VGND VPWR VPWR sky130_fd_sc_hd__decap_3
XFILLER_1_152 VGND VGND VPWR VPWR sky130_fd_sc_hd__decap_3
XFILLER_104_592 VGND VGND VPWR VPWR sky130_fd_sc_hd__decap_3
XFILLER_49_178 VGND VGND VPWR VPWR sky130_fd_sc_hd__decap_3
XFILLER_65_638 VGND VGND VPWR VPWR sky130_fd_sc_hd__decap_3
XFILLER_64_137 VGND VGND VPWR VPWR sky130_fd_sc_hd__decap_3
XFILLER_64_148 VGND VGND VPWR VPWR sky130_fd_sc_hd__decap_3
XFILLER_92_468 VGND VGND VPWR VPWR sky130_fd_sc_hd__decap_3
XFILLER_18_565 VGND VGND VPWR VPWR sky130_fd_sc_hd__fill_2
XFILLER_18_587 VGND VGND VPWR VPWR sky130_fd_sc_hd__fill_1
XFILLER_45_340 VGND VGND VPWR VPWR sky130_fd_sc_hd__decap_3
XFILLER_45_351 VGND VGND VPWR VPWR sky130_fd_sc_hd__decap_3
XTAP_TAPCELL_ROW_28_560 VGND VPWR sky130_fd_sc_hd__tapvpwrvgnd_1
XFILLER_18_598 VGND VGND VPWR VPWR sky130_fd_sc_hd__decap_3
XFILLER_33_524 VGND VGND VPWR VPWR sky130_fd_sc_hd__decap_3
XFILLER_45_373 VGND VGND VPWR VPWR sky130_fd_sc_hd__fill_1
XFILLER_60_332 VGND VGND VPWR VPWR sky130_fd_sc_hd__decap_3
XTAP_TAPCELL_ROW_56_880 VGND VPWR sky130_fd_sc_hd__tapvpwrvgnd_1
XFILLER_33_557 VGND VGND VPWR VPWR sky130_fd_sc_hd__decap_3
XFILLER_54_91 VGND VGND VPWR VPWR sky130_fd_sc_hd__fill_2
XFILLER_60_398 VGND VGND VPWR VPWR sky130_fd_sc_hd__decap_3
X_3730_ _6956_/Q _3883_/A2 _3884_/B1 _6950_/Q _3729_/X VGND VGND VPWR VPWR _3730_/X
+ sky130_fd_sc_hd__a221o_2
XFILLER_13_281 VGND VGND VPWR VPWR sky130_fd_sc_hd__fill_2
X_3661_ _3991_/B _3665_/B VGND VGND VPWR VPWR _3661_/X sky130_fd_sc_hd__and2_4
XFILLER_9_274 VGND VGND VPWR VPWR sky130_fd_sc_hd__decap_3
XFILLER_62_3 VGND VGND VPWR VPWR sky130_fd_sc_hd__decap_3
Xclkload11 _7383_/CLK VGND VGND VPWR VPWR clkload11/Y sky130_fd_sc_hd__inv_6
Xclkload22 _6974_/CLK VGND VGND VPWR VPWR clkload22/X sky130_fd_sc_hd__clkbuf_8
Xclkload33 _7361_/CLK VGND VGND VPWR VPWR clkload33/X sky130_fd_sc_hd__clkbuf_8
X_6380_ _6601_/A VGND VGND VPWR VPWR _6380_/Y sky130_fd_sc_hd__inv_2
X_5400_ _5400_/A0 _5011_/X _5400_/S VGND VGND VPWR VPWR _7133_/D sky130_fd_sc_hd__mux2_2
X_3592_ _4292_/B _3620_/C _3591_/Y VGND VGND VPWR VPWR _3592_/X sky130_fd_sc_hd__a21o_2
X_5331_ _5331_/A0 _5011_/X _5358_/S VGND VGND VPWR VPWR _7165_/D sky130_fd_sc_hd__mux2_2
XFILLER_87_218 VGND VGND VPWR VPWR sky130_fd_sc_hd__decap_3
X_7001_ _7374_/CLK _7001_/D _6281_/Y VGND VGND VPWR VPWR _7001_/Q sky130_fd_sc_hd__dfrtp_2
X_5262_ _5262_/A0 _4978_/X _5274_/S VGND VGND VPWR VPWR _7199_/D sky130_fd_sc_hd__mux2_2
XFILLER_102_529 VGND VGND VPWR VPWR sky130_fd_sc_hd__decap_3
XFILLER_68_410 VGND VGND VPWR VPWR sky130_fd_sc_hd__decap_3
XFILLER_68_421 VGND VGND VPWR VPWR sky130_fd_sc_hd__fill_1
X_4213_ _7292_/Q _4534_/S _4261_/A2 _7356_/Q _4338_/C1 VGND VGND VPWR VPWR _4213_/X
+ sky130_fd_sc_hd__a221o_2
XFILLER_95_251 VGND VGND VPWR VPWR sky130_fd_sc_hd__decap_3
X_4144_ _7362_/Q _4419_/B1 _4261_/B1 _7170_/Q VGND VGND VPWR VPWR _4144_/X sky130_fd_sc_hd__a22o_2
XFILLER_55_104 VGND VGND VPWR VPWR sky130_fd_sc_hd__decap_3
XFILLER_56_627 VGND VGND VPWR VPWR sky130_fd_sc_hd__decap_3
XFILLER_68_487 VGND VGND VPWR VPWR sky130_fd_sc_hd__decap_3
XFILLER_83_424 VGND VGND VPWR VPWR sky130_fd_sc_hd__decap_3
XFILLER_95_284 VGND VGND VPWR VPWR sky130_fd_sc_hd__decap_3
X_4075_ _7211_/Q _3939_/S _4946_/S _7307_/Q VGND VGND VPWR VPWR _4075_/X sky130_fd_sc_hd__a22o_2
XFILLER_36_362 VGND VGND VPWR VPWR sky130_fd_sc_hd__fill_2
XFILLER_55_159 VGND VGND VPWR VPWR sky130_fd_sc_hd__decap_3
XFILLER_24_513 VGND VGND VPWR VPWR sky130_fd_sc_hd__decap_3
XFILLER_24_524 VGND VGND VPWR VPWR sky130_fd_sc_hd__decap_3
XFILLER_24_546 VGND VGND VPWR VPWR sky130_fd_sc_hd__decap_3
XFILLER_70_118 VGND VGND VPWR VPWR sky130_fd_sc_hd__decap_3
XFILLER_91_490 VGND VGND VPWR VPWR sky130_fd_sc_hd__decap_3
XFILLER_24_568 VGND VGND VPWR VPWR sky130_fd_sc_hd__decap_3
XPHY_EDGE_ROW_90_Left_199 VGND VGND VPWR VPWR sky130_fd_sc_hd__decap_3
X_6716_ _7083_/CLK _6716_/D VGND VGND VPWR VPWR _6716_/Q sky130_fd_sc_hd__dfxtp_2
X_4977_ _4977_/A _4977_/B VGND VGND VPWR VPWR _6993_/D sky130_fd_sc_hd__nor2_2
Xclkload5 clkload5/A VGND VGND VPWR VPWR clkload5/X sky130_fd_sc_hd__clkbuf_1
X_3928_ hold972/X _5138_/S _3927_/X VGND VGND VPWR VPWR _7375_/D sky130_fd_sc_hd__o21a_2
X_6647_ _6650_/A VGND VGND VPWR VPWR _6647_/Y sky130_fd_sc_hd__inv_2
X_3859_ _6924_/Q _3926_/A2 _3889_/A2 _6788_/Q _3858_/X VGND VGND VPWR VPWR _3859_/X
+ sky130_fd_sc_hd__a221o_2
X_6578_ _6613_/A VGND VGND VPWR VPWR _6578_/Y sky130_fd_sc_hd__inv_2
XFILLER_3_417 VGND VGND VPWR VPWR sky130_fd_sc_hd__decap_3
XFILLER_105_334 VGND VGND VPWR VPWR sky130_fd_sc_hd__fill_2
XFILLER_105_356 VGND VGND VPWR VPWR sky130_fd_sc_hd__decap_3
XTAP_TAPCELL_ROW_70_1042 VGND VPWR sky130_fd_sc_hd__tapvpwrvgnd_1
XFILLER_101_573 VGND VGND VPWR VPWR sky130_fd_sc_hd__decap_3
XFILLER_47_638 VGND VGND VPWR VPWR sky130_fd_sc_hd__decap_3
XFILLER_74_424 VGND VGND VPWR VPWR sky130_fd_sc_hd__decap_3
XFILLER_86_251 VGND VGND VPWR VPWR sky130_fd_sc_hd__fill_1
XTAP_TAPCELL_ROW_6_299 VGND VPWR sky130_fd_sc_hd__tapvpwrvgnd_1
XFILLER_46_159 VGND VGND VPWR VPWR sky130_fd_sc_hd__decap_3
XFILLER_15_557 VGND VGND VPWR VPWR sky130_fd_sc_hd__decap_3
XFILLER_15_579 VGND VGND VPWR VPWR sky130_fd_sc_hd__decap_3
XFILLER_30_527 VGND VGND VPWR VPWR sky130_fd_sc_hd__decap_3
XFILLER_42_365 VGND VGND VPWR VPWR sky130_fd_sc_hd__decap_3
XFILLER_24_61 VGND VGND VPWR VPWR sky130_fd_sc_hd__decap_3
XTAP_TAPCELL_ROW_81_1171 VGND VPWR sky130_fd_sc_hd__tapvpwrvgnd_1
XFILLER_10_262 VGND VGND VPWR VPWR sky130_fd_sc_hd__decap_3
XFILLER_6_200 VGND VGND VPWR VPWR sky130_fd_sc_hd__decap_3
XFILLER_108_161 VGND VGND VPWR VPWR sky130_fd_sc_hd__decap_3
XFILLER_108_183 VGND VGND VPWR VPWR sky130_fd_sc_hd__decap_3
XFILLER_97_505 VGND VGND VPWR VPWR sky130_fd_sc_hd__decap_3
XFILLER_69_218 VGND VGND VPWR VPWR sky130_fd_sc_hd__decap_3
XFILLER_97_549 VGND VGND VPWR VPWR sky130_fd_sc_hd__decap_3
XFILLER_97_538 VGND VGND VPWR VPWR sky130_fd_sc_hd__fill_2
XFILLER_77_240 VGND VGND VPWR VPWR sky130_fd_sc_hd__decap_3
XFILLER_1_21 VGND VGND VPWR VPWR sky130_fd_sc_hd__fill_1
XFILLER_38_627 VGND VGND VPWR VPWR sky130_fd_sc_hd__decap_3
XFILLER_65_457 VGND VGND VPWR VPWR sky130_fd_sc_hd__fill_2
XFILLER_53_608 VGND VGND VPWR VPWR sky130_fd_sc_hd__decap_3
XFILLER_92_265 VGND VGND VPWR VPWR sky130_fd_sc_hd__fill_2
XFILLER_33_332 VGND VGND VPWR VPWR sky130_fd_sc_hd__fill_1
XFILLER_33_354 VGND VGND VPWR VPWR sky130_fd_sc_hd__decap_3
XFILLER_61_641 VGND VGND VPWR VPWR sky130_fd_sc_hd__decap_3
X_4831_ _4969_/B _4827_/X _4828_/X _4830_/X VGND VGND VPWR VPWR _5657_/A sky130_fd_sc_hd__a211o_2
XFILLER_21_505 VGND VGND VPWR VPWR sky130_fd_sc_hd__decap_3
XFILLER_60_173 VGND VGND VPWR VPWR sky130_fd_sc_hd__decap_3
X_4762_ _4762_/A _4762_/B VGND VGND VPWR VPWR _4762_/Y sky130_fd_sc_hd__nor2_2
X_6501_ _6628_/A VGND VGND VPWR VPWR _6501_/Y sky130_fd_sc_hd__inv_2
X_4693_ _7007_/Q _4750_/B VGND VGND VPWR VPWR _4728_/A sky130_fd_sc_hd__nand2_2
X_3713_ _3733_/C VGND VGND VPWR VPWR _3746_/C sky130_fd_sc_hd__inv_4
X_6432_ _6632_/A VGND VGND VPWR VPWR _6432_/Y sky130_fd_sc_hd__inv_2
X_3644_ _3629_/Y _3642_/X _3867_/B1 VGND VGND VPWR VPWR _4664_/B sky130_fd_sc_hd__o21a_2
XTAP_TAPCELL_ROW_31_588 VGND VPWR sky130_fd_sc_hd__tapvpwrvgnd_1
XTAP_TAPCELL_ROW_95_1329 VGND VPWR sky130_fd_sc_hd__tapvpwrvgnd_1
X_6363_ _6364_/A VGND VGND VPWR VPWR _6363_/Y sky130_fd_sc_hd__inv_2
X_3575_ _7156_/Q _3366_/X _4341_/B1 _7124_/Q _3574_/X VGND VGND VPWR VPWR _3575_/X
+ sky130_fd_sc_hd__a221o_2
X_6294_ _6601_/A VGND VGND VPWR VPWR _6294_/Y sky130_fd_sc_hd__inv_2
XFILLER_102_315 VGND VGND VPWR VPWR sky130_fd_sc_hd__decap_3
XFILLER_88_527 VGND VGND VPWR VPWR sky130_fd_sc_hd__fill_2
X_5245_ _5245_/A0 _4836_/X _5276_/S VGND VGND VPWR VPWR _7207_/D sky130_fd_sc_hd__mux2_2
XTAP_TAPCELL_ROW_59_909 VGND VPWR sky130_fd_sc_hd__tapvpwrvgnd_1
XFILLER_29_605 VGND VGND VPWR VPWR sky130_fd_sc_hd__decap_3
XFILLER_29_638 VGND VGND VPWR VPWR sky130_fd_sc_hd__decap_3
XFILLER_56_413 VGND VGND VPWR VPWR sky130_fd_sc_hd__decap_3
XFILLER_68_262 VGND VGND VPWR VPWR sky130_fd_sc_hd__decap_3
XFILLER_56_446 VGND VGND VPWR VPWR sky130_fd_sc_hd__decap_3
XTAP_TAPCELL_ROW_3_269 VGND VPWR sky130_fd_sc_hd__tapvpwrvgnd_1
XFILLER_28_159 VGND VGND VPWR VPWR sky130_fd_sc_hd__fill_2
XFILLER_44_619 VGND VGND VPWR VPWR sky130_fd_sc_hd__decap_3
XFILLER_45_38 VGND VGND VPWR VPWR sky130_fd_sc_hd__fill_2
XFILLER_56_468 VGND VGND VPWR VPWR sky130_fd_sc_hd__decap_3
XFILLER_71_416 VGND VGND VPWR VPWR sky130_fd_sc_hd__decap_3
XFILLER_83_254 VGND VGND VPWR VPWR sky130_fd_sc_hd__fill_2
XFILLER_83_265 VGND VGND VPWR VPWR sky130_fd_sc_hd__decap_3
X_4058_ _7244_/Q _4430_/A2 _4459_/C1 _7180_/Q _4057_/X VGND VGND VPWR VPWR _4058_/X
+ sky130_fd_sc_hd__a221o_2
XFILLER_71_449 VGND VGND VPWR VPWR sky130_fd_sc_hd__decap_3
XTAP_TAPCELL_ROW_39_688 VGND VPWR sky130_fd_sc_hd__tapvpwrvgnd_1
XFILLER_24_321 VGND VGND VPWR VPWR sky130_fd_sc_hd__decap_3
XFILLER_24_354 VGND VGND VPWR VPWR sky130_fd_sc_hd__decap_3
XFILLER_36_192 VGND VGND VPWR VPWR sky130_fd_sc_hd__decap_3
XFILLER_52_630 VGND VGND VPWR VPWR sky130_fd_sc_hd__decap_3
XTAP_TAPCELL_ROW_104_1436 VGND VPWR sky130_fd_sc_hd__tapvpwrvgnd_1
XTAP_TAPCELL_ROW_104_1425 VGND VPWR sky130_fd_sc_hd__tapvpwrvgnd_1
XFILLER_12_505 VGND VGND VPWR VPWR sky130_fd_sc_hd__decap_3
XFILLER_24_365 VGND VGND VPWR VPWR sky130_fd_sc_hd__fill_2
XFILLER_61_37 VGND VGND VPWR VPWR sky130_fd_sc_hd__decap_3
XFILLER_106_610 VGND VGND VPWR VPWR sky130_fd_sc_hd__decap_3
XFILLER_3_225 VGND VGND VPWR VPWR sky130_fd_sc_hd__decap_3
XFILLER_105_142 VGND VGND VPWR VPWR sky130_fd_sc_hd__decap_3
XFILLER_79_505 VGND VGND VPWR VPWR sky130_fd_sc_hd__decap_3
XFILLER_10_96 VGND VGND VPWR VPWR sky130_fd_sc_hd__fill_2
XFILLER_105_197 VGND VGND VPWR VPWR sky130_fd_sc_hd__decap_3
XFILLER_101_370 VGND VGND VPWR VPWR sky130_fd_sc_hd__decap_3
XFILLER_19_137 VGND VGND VPWR VPWR sky130_fd_sc_hd__decap_3
XFILLER_19_50 VGND VGND VPWR VPWR sky130_fd_sc_hd__decap_3
XFILLER_19_72 VGND VGND VPWR VPWR sky130_fd_sc_hd__decap_3
XFILLER_19_83 VGND VGND VPWR VPWR sky130_fd_sc_hd__decap_3
XFILLER_47_435 VGND VGND VPWR VPWR sky130_fd_sc_hd__fill_1
XFILLER_47_457 VGND VGND VPWR VPWR sky130_fd_sc_hd__decap_3
XFILLER_47_468 VGND VGND VPWR VPWR sky130_fd_sc_hd__decap_3
XFILLER_15_321 VGND VGND VPWR VPWR sky130_fd_sc_hd__decap_3
XFILLER_15_343 VGND VGND VPWR VPWR sky130_fd_sc_hd__decap_3
XFILLER_43_641 VGND VGND VPWR VPWR sky130_fd_sc_hd__decap_3
XFILLER_15_387 VGND VGND VPWR VPWR sky130_fd_sc_hd__decap_3
XFILLER_30_302 VGND VGND VPWR VPWR sky130_fd_sc_hd__decap_3
XFILLER_35_93 VGND VGND VPWR VPWR sky130_fd_sc_hd__decap_3
XFILLER_42_173 VGND VGND VPWR VPWR sky130_fd_sc_hd__decap_3
XFILLER_30_368 VGND VGND VPWR VPWR sky130_fd_sc_hd__decap_3
XFILLER_11_582 VGND VGND VPWR VPWR sky130_fd_sc_hd__decap_3
XFILLER_51_70 VGND VGND VPWR VPWR sky130_fd_sc_hd__decap_3
XFILLER_7_531 VGND VGND VPWR VPWR sky130_fd_sc_hd__decap_3
XFILLER_51_92 VGND VGND VPWR VPWR sky130_fd_sc_hd__decap_3
XFILLER_7_564 VGND VGND VPWR VPWR sky130_fd_sc_hd__decap_3
XFILLER_7_597 VGND VGND VPWR VPWR sky130_fd_sc_hd__decap_3
X_3360_ _3365_/A _5129_/B _3371_/A VGND VGND VPWR VPWR _3386_/B sky130_fd_sc_hd__mux2_2
XFILLER_97_302 VGND VGND VPWR VPWR sky130_fd_sc_hd__decap_3
XFILLER_85_508 VGND VGND VPWR VPWR sky130_fd_sc_hd__decap_3
X_5030_ _6989_/Q _5044_/A VGND VGND VPWR VPWR _6989_/D sky130_fd_sc_hd__xor2_2
XFILLER_97_346 VGND VGND VPWR VPWR sky130_fd_sc_hd__decap_3
XFILLER_97_335 VGND VGND VPWR VPWR sky130_fd_sc_hd__fill_1
Xhold1209 _7360_/Q VGND VGND VPWR VPWR _5708_/A0 sky130_fd_sc_hd__dlygate4sd3_1
XFILLER_26_608 VGND VGND VPWR VPWR sky130_fd_sc_hd__decap_3
X_6981_ _7382_/CLK _6981_/D _6261_/Y VGND VGND VPWR VPWR _6981_/Q sky130_fd_sc_hd__dfrtp_2
XFILLER_65_287 VGND VGND VPWR VPWR sky130_fd_sc_hd__decap_3
XTAP_TAPCELL_ROW_0_239 VGND VPWR sky130_fd_sc_hd__tapvpwrvgnd_1
XTAP_TAPCELL_ROW_0_228 VGND VPWR sky130_fd_sc_hd__tapvpwrvgnd_1
XFILLER_18_192 VGND VGND VPWR VPWR sky130_fd_sc_hd__decap_3
XFILLER_34_641 VGND VGND VPWR VPWR sky130_fd_sc_hd__decap_3
XFILLER_46_490 VGND VGND VPWR VPWR sky130_fd_sc_hd__decap_3
XFILLER_80_246 VGND VGND VPWR VPWR sky130_fd_sc_hd__decap_3
XTAP_TAPCELL_ROW_64_967 VGND VPWR sky130_fd_sc_hd__tapvpwrvgnd_1
XTAP_TAPCELL_ROW_36_647 VGND VPWR sky130_fd_sc_hd__tapvpwrvgnd_1
XFILLER_21_335 VGND VGND VPWR VPWR sky130_fd_sc_hd__fill_1
XFILLER_33_195 VGND VGND VPWR VPWR sky130_fd_sc_hd__decap_3
X_4814_ _4814_/A _4814_/B VGND VGND VPWR VPWR _4814_/Y sky130_fd_sc_hd__nor2_2
XFILLER_21_357 VGND VGND VPWR VPWR sky130_fd_sc_hd__decap_3
X_4745_ _4745_/A VGND VGND VPWR VPWR _4745_/Y sky130_fd_sc_hd__inv_2
X_4676_ _5648_/A _5067_/B _6985_/Q _6986_/Q _6987_/Q VGND VGND VPWR VPWR _5045_/B
+ sky130_fd_sc_hd__o2111a_2
X_7395_ _7397_/CLK _7395_/D _6675_/Y VGND VGND VPWR VPWR _7395_/Q sky130_fd_sc_hd__dfrtp_2
X_6415_ _6646_/A VGND VGND VPWR VPWR _6415_/Y sky130_fd_sc_hd__inv_2
X_3627_ _3746_/A _3746_/B _3733_/C VGND VGND VPWR VPWR _5660_/A sky130_fd_sc_hd__and3_2
X_6346_ _6668_/A VGND VGND VPWR VPWR _6346_/Y sky130_fd_sc_hd__inv_2
X_3558_ _7061_/Q _3558_/B VGND VGND VPWR VPWR _3558_/X sky130_fd_sc_hd__or2_2
XFILLER_0_228 VGND VGND VPWR VPWR sky130_fd_sc_hd__decap_3
XFILLER_103_635 VGND VGND VPWR VPWR sky130_fd_sc_hd__decap_3
XTAP_TAPCELL_ROW_8_328 VGND VPWR sky130_fd_sc_hd__tapvpwrvgnd_1
XFILLER_88_368 VGND VGND VPWR VPWR sky130_fd_sc_hd__fill_2
X_6277_ _6278_/A VGND VGND VPWR VPWR _6277_/Y sky130_fd_sc_hd__inv_2
X_3489_ _7311_/Q _4471_/S _3380_/Y _7343_/Q _3488_/X VGND VGND VPWR VPWR _3489_/X
+ sky130_fd_sc_hd__a221o_2
XFILLER_102_156 VGND VGND VPWR VPWR sky130_fd_sc_hd__decap_3
XFILLER_76_519 VGND VGND VPWR VPWR sky130_fd_sc_hd__decap_3
X_5228_ _5238_/B VGND VGND VPWR VPWR _5229_/B sky130_fd_sc_hd__inv_2
XFILLER_56_210 VGND VGND VPWR VPWR sky130_fd_sc_hd__fill_2
XFILLER_56_26 VGND VGND VPWR VPWR sky130_fd_sc_hd__fill_2
XFILLER_56_37 VGND VGND VPWR VPWR sky130_fd_sc_hd__decap_3
X_5159_ _5159_/A0 _4470_/X _5159_/S VGND VGND VPWR VPWR _7247_/D sky130_fd_sc_hd__mux2_2
XFILLER_29_457 VGND VGND VPWR VPWR sky130_fd_sc_hd__decap_3
XFILLER_44_405 VGND VGND VPWR VPWR sky130_fd_sc_hd__decap_3
XFILLER_56_59 VGND VGND VPWR VPWR sky130_fd_sc_hd__fill_2
XFILLER_44_416 VGND VGND VPWR VPWR sky130_fd_sc_hd__decap_3
XFILLER_44_438 VGND VGND VPWR VPWR sky130_fd_sc_hd__decap_3
XFILLER_25_641 VGND VGND VPWR VPWR sky130_fd_sc_hd__decap_3
Xclkbuf_leaf_36_clk clkbuf_3_2__f_clk/X VGND VGND VPWR VPWR _7350_/CLK sky130_fd_sc_hd__clkbuf_16
XFILLER_40_633 VGND VGND VPWR VPWR sky130_fd_sc_hd__decap_3
XFILLER_52_493 VGND VGND VPWR VPWR sky130_fd_sc_hd__decap_3
XFILLER_8_339 VGND VGND VPWR VPWR sky130_fd_sc_hd__fill_1
XFILLER_21_84 VGND VGND VPWR VPWR sky130_fd_sc_hd__decap_3
XFILLER_4_545 VGND VGND VPWR VPWR sky130_fd_sc_hd__decap_3
XFILLER_106_473 VGND VGND VPWR VPWR sky130_fd_sc_hd__decap_3
XFILLER_4_578 VGND VGND VPWR VPWR sky130_fd_sc_hd__decap_3
XFILLER_4_589 VGND VGND VPWR VPWR sky130_fd_sc_hd__decap_3
XFILLER_79_346 VGND VGND VPWR VPWR sky130_fd_sc_hd__decap_3
XFILLER_67_508 VGND VGND VPWR VPWR sky130_fd_sc_hd__decap_3
XFILLER_67_519 VGND VGND VPWR VPWR sky130_fd_sc_hd__fill_2
XFILLER_79_368 VGND VGND VPWR VPWR sky130_fd_sc_hd__decap_3
XFILLER_94_305 VGND VGND VPWR VPWR sky130_fd_sc_hd__decap_3
XFILLER_47_221 VGND VGND VPWR VPWR sky130_fd_sc_hd__decap_3
XFILLER_94_327 VGND VGND VPWR VPWR sky130_fd_sc_hd__decap_3
XFILLER_47_265 VGND VGND VPWR VPWR sky130_fd_sc_hd__fill_1
XFILLER_75_574 VGND VGND VPWR VPWR sky130_fd_sc_hd__fill_1
XFILLER_35_427 VGND VGND VPWR VPWR sky130_fd_sc_hd__fill_1
XFILLER_35_438 VGND VGND VPWR VPWR sky130_fd_sc_hd__decap_3
XFILLER_62_224 VGND VGND VPWR VPWR sky130_fd_sc_hd__decap_3
XFILLER_35_449 VGND VGND VPWR VPWR sky130_fd_sc_hd__decap_3
XFILLER_90_544 VGND VGND VPWR VPWR sky130_fd_sc_hd__decap_3
Xclkbuf_leaf_27_clk clkbuf_3_6__f_clk/X VGND VGND VPWR VPWR _7364_/CLK sky130_fd_sc_hd__clkbuf_16
XTAP_TAPCELL_ROW_61_937 VGND VPWR sky130_fd_sc_hd__tapvpwrvgnd_1
XTAP_TAPCELL_ROW_33_617 VGND VPWR sky130_fd_sc_hd__tapvpwrvgnd_1
XFILLER_31_644 VGND VGND VPWR VPWR sky130_fd_sc_hd__decap_3
XFILLER_30_132 VGND VGND VPWR VPWR sky130_fd_sc_hd__decap_3
XFILLER_7_20 VGND VGND VPWR VPWR sky130_fd_sc_hd__fill_2
XTAP_TAPCELL_ROW_13_385 VGND VPWR sky130_fd_sc_hd__tapvpwrvgnd_1
XFILLER_11_390 VGND VGND VPWR VPWR sky130_fd_sc_hd__fill_2
XFILLER_7_350 VGND VGND VPWR VPWR sky130_fd_sc_hd__decap_3
X_4530_ _4530_/A0 _7282_/Q _4532_/S VGND VGND VPWR VPWR _7314_/D sky130_fd_sc_hd__mux2_2
XFILLER_7_383 VGND VGND VPWR VPWR sky130_fd_sc_hd__decap_3
XFILLER_7_86 VGND VGND VPWR VPWR sky130_fd_sc_hd__decap_3
X_7180_ _7276_/CLK _7180_/D _6460_/Y VGND VGND VPWR VPWR _7180_/Q sky130_fd_sc_hd__dfrtp_2
X_3412_ _7187_/Q _3994_/S _4285_/B1 _7379_/Q VGND VGND VPWR VPWR _3412_/X sky130_fd_sc_hd__a22o_2
X_4392_ _7369_/Q _4394_/B _4434_/B1 _7145_/Q _4391_/X VGND VGND VPWR VPWR _4392_/X
+ sky130_fd_sc_hd__a221o_2
XFILLER_97_143 VGND VGND VPWR VPWR sky130_fd_sc_hd__decap_3
Xhold1006 _7244_/Q VGND VGND VPWR VPWR _5167_/A sky130_fd_sc_hd__dlygate4sd3_1
XFILLER_85_327 VGND VGND VPWR VPWR sky130_fd_sc_hd__decap_3
Xhold1017 _7197_/Q VGND VGND VPWR VPWR _5266_/A0 sky130_fd_sc_hd__dlygate4sd3_1
Xhold1028 _7210_/Q VGND VGND VPWR VPWR _5240_/B2 sky130_fd_sc_hd__dlygate4sd3_1
Xhold1039 _7194_/Q VGND VGND VPWR VPWR _5272_/A0 sky130_fd_sc_hd__dlygate4sd3_1
XFILLER_97_187 VGND VGND VPWR VPWR sky130_fd_sc_hd__decap_3
XFILLER_66_552 VGND VGND VPWR VPWR sky130_fd_sc_hd__decap_3
XFILLER_26_29 VGND VGND VPWR VPWR sky130_fd_sc_hd__decap_3
XFILLER_38_265 VGND VGND VPWR VPWR sky130_fd_sc_hd__decap_3
XFILLER_38_298 VGND VGND VPWR VPWR sky130_fd_sc_hd__decap_3
XFILLER_81_511 VGND VGND VPWR VPWR sky130_fd_sc_hd__decap_3
XTAP_TAPCELL_ROW_49_794 VGND VPWR sky130_fd_sc_hd__tapvpwrvgnd_1
XFILLER_19_490 VGND VGND VPWR VPWR sky130_fd_sc_hd__decap_3
XFILLER_53_246 VGND VGND VPWR VPWR sky130_fd_sc_hd__decap_3
Xclkbuf_leaf_18_clk clkbuf_leaf_9_clk/A VGND VGND VPWR VPWR _7397_/CLK sky130_fd_sc_hd__clkbuf_16
X_6964_ clkload6/A _6964_/D VGND VGND VPWR VPWR _6964_/Q sky130_fd_sc_hd__dfxtp_2
XPHY_EDGE_ROW_5_Right_5 VGND VGND VPWR VPWR sky130_fd_sc_hd__decap_3
XFILLER_53_279 VGND VGND VPWR VPWR sky130_fd_sc_hd__fill_1
X_6895_ _6943_/CLK _6895_/D VGND VGND VPWR VPWR _6895_/Q sky130_fd_sc_hd__dfxtp_2
XFILLER_22_622 VGND VGND VPWR VPWR sky130_fd_sc_hd__decap_3
XFILLER_34_493 VGND VGND VPWR VPWR sky130_fd_sc_hd__fill_1
XFILLER_21_154 VGND VGND VPWR VPWR sky130_fd_sc_hd__decap_3
XFILLER_21_198 VGND VGND VPWR VPWR sky130_fd_sc_hd__decap_3
XFILLER_5_309 VGND VGND VPWR VPWR sky130_fd_sc_hd__decap_3
X_4728_ _4728_/A _4728_/B VGND VGND VPWR VPWR _4729_/B sky130_fd_sc_hd__nand2_2
X_4659_ _4814_/A _4457_/X _4658_/Y _4852_/A _4040_/Y VGND VGND VPWR VPWR _4659_/X
+ sky130_fd_sc_hd__o2111a_2
XFILLER_1_526 VGND VGND VPWR VPWR sky130_fd_sc_hd__decap_3
X_7378_ _7383_/CLK _7378_/D _6658_/Y VGND VGND VPWR VPWR _7378_/Q sky130_fd_sc_hd__dfrtp_2
Xhold840 _7061_/Q VGND VGND VPWR VPWR _7061_/D sky130_fd_sc_hd__dlygate4sd3_1
Xhold851 _7104_/Q VGND VGND VPWR VPWR _7104_/D sky130_fd_sc_hd__dlygate4sd3_1
Xhold862 _7112_/Q VGND VGND VPWR VPWR _7112_/D sky130_fd_sc_hd__dlygate4sd3_1
Xhold873 _7087_/Q VGND VGND VPWR VPWR _7087_/D sky130_fd_sc_hd__dlygate4sd3_1
XFILLER_107_43 VGND VGND VPWR VPWR sky130_fd_sc_hd__decap_3
XFILLER_1_559 VGND VGND VPWR VPWR sky130_fd_sc_hd__fill_1
Xhold884 _7077_/Q VGND VGND VPWR VPWR _7077_/D sky130_fd_sc_hd__dlygate4sd3_1
Xhold895 _7109_/Q VGND VGND VPWR VPWR _7109_/D sky130_fd_sc_hd__dlygate4sd3_1
X_6329_ _6680_/A VGND VGND VPWR VPWR _6329_/Y sky130_fd_sc_hd__inv_2
XFILLER_107_87 VGND VGND VPWR VPWR sky130_fd_sc_hd__decap_3
XFILLER_76_305 VGND VGND VPWR VPWR sky130_fd_sc_hd__decap_3
XFILLER_67_69 VGND VGND VPWR VPWR sky130_fd_sc_hd__fill_1
XFILLER_76_349 VGND VGND VPWR VPWR sky130_fd_sc_hd__decap_3
XFILLER_29_243 VGND VGND VPWR VPWR sky130_fd_sc_hd__decap_3
XFILLER_17_405 VGND VGND VPWR VPWR sky130_fd_sc_hd__decap_3
XFILLER_57_574 VGND VGND VPWR VPWR sky130_fd_sc_hd__decap_3
XFILLER_72_500 VGND VGND VPWR VPWR sky130_fd_sc_hd__decap_3
XFILLER_72_522 VGND VGND VPWR VPWR sky130_fd_sc_hd__fill_1
XFILLER_84_360 VGND VGND VPWR VPWR sky130_fd_sc_hd__decap_3
XFILLER_84_371 VGND VGND VPWR VPWR sky130_fd_sc_hd__decap_3
XTAP_TAPCELL_ROW_67_1003 VGND VPWR sky130_fd_sc_hd__tapvpwrvgnd_1
XFILLER_72_533 VGND VGND VPWR VPWR sky130_fd_sc_hd__decap_3
XFILLER_72_555 VGND VGND VPWR VPWR sky130_fd_sc_hd__decap_3
XFILLER_84_393 VGND VGND VPWR VPWR sky130_fd_sc_hd__decap_3
XFILLER_13_600 VGND VGND VPWR VPWR sky130_fd_sc_hd__decap_3
XFILLER_16_40 VGND VGND VPWR VPWR sky130_fd_sc_hd__decap_3
XFILLER_16_51 VGND VGND VPWR VPWR sky130_fd_sc_hd__fill_2
XFILLER_32_419 VGND VGND VPWR VPWR sky130_fd_sc_hd__fill_1
XFILLER_44_268 VGND VGND VPWR VPWR sky130_fd_sc_hd__decap_3
XFILLER_44_279 VGND VGND VPWR VPWR sky130_fd_sc_hd__decap_3
XFILLER_13_644 VGND VGND VPWR VPWR sky130_fd_sc_hd__decap_3
XFILLER_12_132 VGND VGND VPWR VPWR sky130_fd_sc_hd__fill_2
XFILLER_9_626 VGND VGND VPWR VPWR sky130_fd_sc_hd__decap_3
XFILLER_9_615 VGND VGND VPWR VPWR sky130_fd_sc_hd__fill_1
XFILLER_12_165 VGND VGND VPWR VPWR sky130_fd_sc_hd__decap_3
XFILLER_40_485 VGND VGND VPWR VPWR sky130_fd_sc_hd__decap_3
XFILLER_32_83 VGND VGND VPWR VPWR sky130_fd_sc_hd__fill_1
XFILLER_8_147 VGND VGND VPWR VPWR sky130_fd_sc_hd__decap_3
XFILLER_8_169 VGND VGND VPWR VPWR sky130_fd_sc_hd__decap_3
XTAP_TAPCELL_ROW_78_1132 VGND VPWR sky130_fd_sc_hd__tapvpwrvgnd_1
XTAP_TAPCELL_ROW_10_355 VGND VPWR sky130_fd_sc_hd__tapvpwrvgnd_1
XTAP_TAPCELL_ROW_10_344 VGND VPWR sky130_fd_sc_hd__tapvpwrvgnd_1
XFILLER_4_342 VGND VGND VPWR VPWR sky130_fd_sc_hd__fill_1
XFILLER_79_121 VGND VGND VPWR VPWR sky130_fd_sc_hd__decap_3
XFILLER_79_143 VGND VGND VPWR VPWR sky130_fd_sc_hd__decap_3
XFILLER_0_570 VGND VGND VPWR VPWR sky130_fd_sc_hd__decap_3
XFILLER_0_581 VGND VGND VPWR VPWR sky130_fd_sc_hd__decap_3
XFILLER_0_592 VGND VGND VPWR VPWR sky130_fd_sc_hd__decap_3
XFILLER_94_102 VGND VGND VPWR VPWR sky130_fd_sc_hd__fill_1
XFILLER_94_124 VGND VGND VPWR VPWR sky130_fd_sc_hd__decap_3
XFILLER_95_636 VGND VGND VPWR VPWR sky130_fd_sc_hd__decap_3
XFILLER_35_202 VGND VGND VPWR VPWR sky130_fd_sc_hd__fill_1
XFILLER_63_511 VGND VGND VPWR VPWR sky130_fd_sc_hd__fill_2
XTAP_TAPCELL_ROW_89_1261 VGND VPWR sky130_fd_sc_hd__tapvpwrvgnd_1
XFILLER_23_408 VGND VGND VPWR VPWR sky130_fd_sc_hd__decap_3
XFILLER_35_279 VGND VGND VPWR VPWR sky130_fd_sc_hd__fill_1
XTAP_TAPCELL_ROW_46_764 VGND VPWR sky130_fd_sc_hd__tapvpwrvgnd_1
XTAP_TAPCELL_ROW_18_444 VGND VPWR sky130_fd_sc_hd__tapvpwrvgnd_1
XFILLER_90_385 VGND VGND VPWR VPWR sky130_fd_sc_hd__decap_3
XFILLER_31_430 VGND VGND VPWR VPWR sky130_fd_sc_hd__decap_3
XFILLER_43_290 VGND VGND VPWR VPWR sky130_fd_sc_hd__fill_2
XFILLER_92_3 VGND VGND VPWR VPWR sky130_fd_sc_hd__fill_1
X_6680_ _6680_/A VGND VGND VPWR VPWR _6680_/Y sky130_fd_sc_hd__inv_2
X_3892_ _6771_/Q _3661_/X _3665_/X _6765_/Q VGND VGND VPWR VPWR _3892_/X sky130_fd_sc_hd__a22o_2
XFILLER_31_463 VGND VGND VPWR VPWR sky130_fd_sc_hd__decap_3
X_7301_ _7366_/CLK _7301_/D _6581_/Y VGND VGND VPWR VPWR _7301_/Q sky130_fd_sc_hd__dfrtp_2
X_4513_ _4513_/A0 _7291_/Q _4520_/S VGND VGND VPWR VPWR _7323_/D sky130_fd_sc_hd__mux2_2
X_7232_ _7364_/CLK _7232_/D _6512_/Y VGND VGND VPWR VPWR _7232_/Q sky130_fd_sc_hd__dfrtp_2
XFILLER_104_218 VGND VGND VPWR VPWR sky130_fd_sc_hd__decap_3
Xclkbuf_leaf_7_clk clkbuf_leaf_7_clk/A VGND VGND VPWR VPWR _7398_/CLK sky130_fd_sc_hd__clkbuf_16
X_4444_ _4396_/A _4444_/B VGND VGND VPWR VPWR _4444_/X sky130_fd_sc_hd__and2b_2
X_7163_ _7352_/CLK _7163_/D _6443_/Y VGND VGND VPWR VPWR _7163_/Q sky130_fd_sc_hd__dfrtp_2
X_4375_ _5003_/A _4374_/X _4988_/A VGND VGND VPWR VPWR _4375_/X sky130_fd_sc_hd__o21ba_2
XFILLER_98_430 VGND VGND VPWR VPWR sky130_fd_sc_hd__decap_3
XFILLER_58_305 VGND VGND VPWR VPWR sky130_fd_sc_hd__decap_3
X_7094_ _7348_/CLK _7094_/D _6374_/Y VGND VGND VPWR VPWR _7094_/Q sky130_fd_sc_hd__dfrtp_2
X_3326_ _5648_/A _3326_/B VGND VGND VPWR VPWR _5238_/B sky130_fd_sc_hd__nor2_2
XFILLER_98_452 VGND VGND VPWR VPWR sky130_fd_sc_hd__decap_3
XFILLER_100_435 VGND VGND VPWR VPWR sky130_fd_sc_hd__decap_3
XFILLER_85_113 VGND VGND VPWR VPWR sky130_fd_sc_hd__decap_3
XFILLER_85_124 VGND VGND VPWR VPWR sky130_fd_sc_hd__decap_3
XFILLER_98_485 VGND VGND VPWR VPWR sky130_fd_sc_hd__decap_3
XFILLER_37_28 VGND VGND VPWR VPWR sky130_fd_sc_hd__decap_3
XFILLER_85_157 VGND VGND VPWR VPWR sky130_fd_sc_hd__decap_3
XFILLER_26_224 VGND VGND VPWR VPWR sky130_fd_sc_hd__decap_3
XFILLER_66_382 VGND VGND VPWR VPWR sky130_fd_sc_hd__decap_3
XFILLER_93_190 VGND VGND VPWR VPWR sky130_fd_sc_hd__decap_3
XFILLER_14_419 VGND VGND VPWR VPWR sky130_fd_sc_hd__fill_1
XFILLER_26_268 VGND VGND VPWR VPWR sky130_fd_sc_hd__fill_1
XFILLER_81_352 VGND VGND VPWR VPWR sky130_fd_sc_hd__decap_3
XFILLER_41_216 VGND VGND VPWR VPWR sky130_fd_sc_hd__fill_1
XFILLER_53_49 VGND VGND VPWR VPWR sky130_fd_sc_hd__decap_3
XFILLER_54_599 VGND VGND VPWR VPWR sky130_fd_sc_hd__decap_3
X_6947_ _6965_/CLK _6947_/D VGND VGND VPWR VPWR _6947_/Q sky130_fd_sc_hd__dfxtp_2
XFILLER_22_430 VGND VGND VPWR VPWR sky130_fd_sc_hd__decap_3
X_6878_ clkload8/A _6878_/D VGND VGND VPWR VPWR _6878_/Q sky130_fd_sc_hd__dfxtp_2
XFILLER_10_625 VGND VGND VPWR VPWR sky130_fd_sc_hd__decap_3
XFILLER_22_474 VGND VGND VPWR VPWR sky130_fd_sc_hd__fill_2
XFILLER_6_607 VGND VGND VPWR VPWR sky130_fd_sc_hd__decap_3
XFILLER_108_513 VGND VGND VPWR VPWR sky130_fd_sc_hd__decap_3
XFILLER_108_557 VGND VGND VPWR VPWR sky130_fd_sc_hd__decap_3
XFILLER_1_334 VGND VGND VPWR VPWR sky130_fd_sc_hd__fill_2
XFILLER_78_35 VGND VGND VPWR VPWR sky130_fd_sc_hd__decap_3
XFILLER_89_441 VGND VGND VPWR VPWR sky130_fd_sc_hd__decap_3
Xhold670 _6719_/Q VGND VGND VPWR VPWR _6719_/D sky130_fd_sc_hd__dlygate4sd3_1
Xhold681 _6842_/Q VGND VGND VPWR VPWR _6842_/D sky130_fd_sc_hd__dlygate4sd3_1
XFILLER_103_240 VGND VGND VPWR VPWR sky130_fd_sc_hd__fill_2
XFILLER_103_251 VGND VGND VPWR VPWR sky130_fd_sc_hd__fill_2
XFILLER_1_345 VGND VGND VPWR VPWR sky130_fd_sc_hd__fill_1
XFILLER_89_452 VGND VGND VPWR VPWR sky130_fd_sc_hd__decap_3
Xhold692 _6734_/Q VGND VGND VPWR VPWR _6734_/D sky130_fd_sc_hd__dlygate4sd3_1
XTAP_TAPCELL_ROW_73_1073 VGND VPWR sky130_fd_sc_hd__tapvpwrvgnd_1
XFILLER_77_647 VGND VGND VPWR VPWR sky130_fd_sc_hd__fill_1
XFILLER_49_349 VGND VGND VPWR VPWR sky130_fd_sc_hd__decap_3
XFILLER_76_157 VGND VGND VPWR VPWR sky130_fd_sc_hd__decap_3
XFILLER_57_360 VGND VGND VPWR VPWR sky130_fd_sc_hd__decap_3
XFILLER_91_127 VGND VGND VPWR VPWR sky130_fd_sc_hd__decap_3
XFILLER_17_213 VGND VGND VPWR VPWR sky130_fd_sc_hd__decap_3
XFILLER_57_382 VGND VGND VPWR VPWR sky130_fd_sc_hd__decap_3
XFILLER_57_393 VGND VGND VPWR VPWR sky130_fd_sc_hd__decap_3
XFILLER_72_330 VGND VGND VPWR VPWR sky130_fd_sc_hd__decap_3
XFILLER_84_190 VGND VGND VPWR VPWR sky130_fd_sc_hd__decap_3
XFILLER_60_503 VGND VGND VPWR VPWR sky130_fd_sc_hd__decap_3
XFILLER_72_374 VGND VGND VPWR VPWR sky130_fd_sc_hd__decap_3
XFILLER_32_227 VGND VGND VPWR VPWR sky130_fd_sc_hd__decap_3
XFILLER_60_536 VGND VGND VPWR VPWR sky130_fd_sc_hd__decap_3
XTAP_TAPCELL_ROW_43_734 VGND VPWR sky130_fd_sc_hd__tapvpwrvgnd_1
XTAP_TAPCELL_ROW_15_403 VGND VPWR sky130_fd_sc_hd__tapvpwrvgnd_1
XFILLER_25_290 VGND VGND VPWR VPWR sky130_fd_sc_hd__decap_3
XFILLER_60_558 VGND VGND VPWR VPWR sky130_fd_sc_hd__decap_3
XFILLER_13_463 VGND VGND VPWR VPWR sky130_fd_sc_hd__decap_3
XFILLER_43_60 VGND VGND VPWR VPWR sky130_fd_sc_hd__decap_3
XFILLER_57_6 VGND VGND VPWR VPWR sky130_fd_sc_hd__decap_3
XFILLER_4_183 VGND VGND VPWR VPWR sky130_fd_sc_hd__decap_3
X_4160_ _7297_/Q _4478_/S _4261_/B1 _7169_/Q _4159_/X VGND VGND VPWR VPWR _4160_/X
+ sky130_fd_sc_hd__a221o_2
XFILLER_68_636 VGND VGND VPWR VPWR sky130_fd_sc_hd__decap_3
XFILLER_95_411 VGND VGND VPWR VPWR sky130_fd_sc_hd__decap_3
XFILLER_67_146 VGND VGND VPWR VPWR sky130_fd_sc_hd__decap_3
XFILLER_95_444 VGND VGND VPWR VPWR sky130_fd_sc_hd__decap_3
X_4091_ _7110_/Q _4434_/A2 _4434_/B1 _7142_/Q _4090_/X VGND VGND VPWR VPWR _4091_/X
+ sky130_fd_sc_hd__a221o_2
XFILLER_95_455 VGND VGND VPWR VPWR sky130_fd_sc_hd__fill_1
XFILLER_36_500 VGND VGND VPWR VPWR sky130_fd_sc_hd__decap_3
XFILLER_48_371 VGND VGND VPWR VPWR sky130_fd_sc_hd__fill_1
XFILLER_55_308 VGND VGND VPWR VPWR sky130_fd_sc_hd__decap_3
XFILLER_82_105 VGND VGND VPWR VPWR sky130_fd_sc_hd__fill_1
XFILLER_83_617 VGND VGND VPWR VPWR sky130_fd_sc_hd__decap_3
XFILLER_95_499 VGND VGND VPWR VPWR sky130_fd_sc_hd__decap_3
XFILLER_36_533 VGND VGND VPWR VPWR sky130_fd_sc_hd__decap_3
XFILLER_23_205 VGND VGND VPWR VPWR sky130_fd_sc_hd__decap_3
XFILLER_36_566 VGND VGND VPWR VPWR sky130_fd_sc_hd__decap_3
XFILLER_51_503 VGND VGND VPWR VPWR sky130_fd_sc_hd__fill_1
Xplace330 _4267_/A2 VGND VGND VPWR VPWR _4434_/B1 sky130_fd_sc_hd__buf_2
X_6801_ _7083_/CLK _6801_/D VGND VGND VPWR VPWR _6801_/Q sky130_fd_sc_hd__dfxtp_2
XFILLER_23_238 VGND VGND VPWR VPWR sky130_fd_sc_hd__decap_3
XFILLER_63_396 VGND VGND VPWR VPWR sky130_fd_sc_hd__decap_3
XFILLER_90_160 VGND VGND VPWR VPWR sky130_fd_sc_hd__decap_3
Xplace363 _4305_/B VGND VGND VPWR VPWR _4265_/B sky130_fd_sc_hd__buf_2
Xplace352 _4998_/S VGND VGND VPWR VPWR _4946_/S sky130_fd_sc_hd__buf_2
Xplace341 _4606_/Y VGND VGND VPWR VPWR _5092_/C sky130_fd_sc_hd__buf_2
X_4993_ _4987_/A _4991_/Y _4992_/Y VGND VGND VPWR VPWR _4993_/X sky130_fd_sc_hd__o21a_2
XFILLER_51_558 VGND VGND VPWR VPWR sky130_fd_sc_hd__fill_2
XFILLER_51_569 VGND VGND VPWR VPWR sky130_fd_sc_hd__decap_3
XFILLER_90_193 VGND VGND VPWR VPWR sky130_fd_sc_hd__decap_3
Xplace374 _3864_/S VGND VGND VPWR VPWR _4832_/A sky130_fd_sc_hd__buf_2
Xplace385 _5225_/B VGND VGND VPWR VPWR _5207_/B sky130_fd_sc_hd__buf_2
Xplace396 _5294_/Y VGND VGND VPWR VPWR _7412_/A sky130_fd_sc_hd__buf_2
X_6732_ clkload7/A _6732_/D VGND VGND VPWR VPWR _6732_/Q sky130_fd_sc_hd__dfxtp_2
X_6663_ _6667_/A VGND VGND VPWR VPWR _6663_/Y sky130_fd_sc_hd__inv_2
X_3875_ hold978/X _5138_/S _3874_/X VGND VGND VPWR VPWR _7383_/D sky130_fd_sc_hd__o21a_2
X_6594_ _6594_/A VGND VGND VPWR VPWR _6594_/Y sky130_fd_sc_hd__inv_2
XFILLER_105_505 VGND VGND VPWR VPWR sky130_fd_sc_hd__decap_3
X_7215_ clkload4/A _7215_/D _6495_/Y VGND VGND VPWR VPWR _7215_/Q sky130_fd_sc_hd__dfrtp_2
XFILLER_59_603 VGND VGND VPWR VPWR sky130_fd_sc_hd__decap_3
X_7146_ _7276_/CLK _7146_/D _6426_/Y VGND VGND VPWR VPWR _7146_/Q sky130_fd_sc_hd__dfrtp_2
XFILLER_58_102 VGND VGND VPWR VPWR sky130_fd_sc_hd__fill_2
XFILLER_59_647 VGND VGND VPWR VPWR sky130_fd_sc_hd__fill_1
XFILLER_86_433 VGND VGND VPWR VPWR sky130_fd_sc_hd__decap_3
X_4358_ _4367_/A _4367_/B _4367_/C VGND VGND VPWR VPWR _5072_/B sky130_fd_sc_hd__a21bo_2
XFILLER_98_271 VGND VGND VPWR VPWR sky130_fd_sc_hd__decap_3
XFILLER_104_11 VGND VGND VPWR VPWR sky130_fd_sc_hd__decap_3
X_7077_ _7397_/CLK _7077_/D _6357_/Y VGND VGND VPWR VPWR _7077_/Q sky130_fd_sc_hd__dfrtp_2
X_4289_ _4537_/C _5708_/S VGND VGND VPWR VPWR _4649_/A sky130_fd_sc_hd__nand2_2
X_3309_ _3371_/A _3365_/A _3353_/B VGND VGND VPWR VPWR _3383_/B sky130_fd_sc_hd__or3_4
XFILLER_39_371 VGND VGND VPWR VPWR sky130_fd_sc_hd__decap_3
XFILLER_73_116 VGND VGND VPWR VPWR sky130_fd_sc_hd__decap_3
XFILLER_74_639 VGND VGND VPWR VPWR sky130_fd_sc_hd__decap_3
XFILLER_86_488 VGND VGND VPWR VPWR sky130_fd_sc_hd__decap_3
XPHY_EDGE_ROW_100_Left_209 VGND VGND VPWR VPWR sky130_fd_sc_hd__decap_3
XFILLER_104_66 VGND VGND VPWR VPWR sky130_fd_sc_hd__fill_1
XFILLER_39_393 VGND VGND VPWR VPWR sky130_fd_sc_hd__decap_3
XFILLER_64_26 VGND VGND VPWR VPWR sky130_fd_sc_hd__fill_2
XFILLER_64_48 VGND VGND VPWR VPWR sky130_fd_sc_hd__decap_3
XTAP_TAPCELL_ROW_107_1467 VGND VPWR sky130_fd_sc_hd__tapvpwrvgnd_1
XFILLER_27_588 VGND VGND VPWR VPWR sky130_fd_sc_hd__decap_3
XFILLER_42_536 VGND VGND VPWR VPWR sky130_fd_sc_hd__decap_3
XFILLER_54_385 VGND VGND VPWR VPWR sky130_fd_sc_hd__decap_3
XFILLER_81_193 VGND VGND VPWR VPWR sky130_fd_sc_hd__decap_3
Xfanout20 _6344_/A VGND VGND VPWR VPWR _6667_/A sky130_fd_sc_hd__buf_2
Xfanout31 _6635_/A VGND VGND VPWR VPWR _6592_/A sky130_fd_sc_hd__buf_2
Xfanout42 _6608_/A VGND VGND VPWR VPWR _6640_/A sky130_fd_sc_hd__buf_1
Xfanout53 fanout67/X VGND VGND VPWR VPWR _6485_/A sky130_fd_sc_hd__buf_1
Xfanout64 _6616_/A VGND VGND VPWR VPWR _6622_/A sky130_fd_sc_hd__buf_2
XFILLER_10_433 VGND VGND VPWR VPWR sky130_fd_sc_hd__decap_3
XFILLER_10_477 VGND VGND VPWR VPWR sky130_fd_sc_hd__decap_3
XFILLER_13_52 VGND VGND VPWR VPWR sky130_fd_sc_hd__decap_3
XFILLER_13_74 VGND VGND VPWR VPWR sky130_fd_sc_hd__fill_1
XTAP_TAPCELL_ROW_20_461 VGND VPWR sky130_fd_sc_hd__tapvpwrvgnd_1
XFILLER_108_365 VGND VGND VPWR VPWR sky130_fd_sc_hd__decap_3
XFILLER_89_45 VGND VGND VPWR VPWR sky130_fd_sc_hd__decap_3
XTAP_TAPCELL_ROW_75_1102 VGND VPWR sky130_fd_sc_hd__tapvpwrvgnd_1
XFILLER_2_610 VGND VGND VPWR VPWR sky130_fd_sc_hd__decap_3
XFILLER_2_643 VGND VGND VPWR VPWR sky130_fd_sc_hd__fill_1
XFILLER_104_571 VGND VGND VPWR VPWR sky130_fd_sc_hd__decap_3
XFILLER_1_164 VGND VGND VPWR VPWR sky130_fd_sc_hd__decap_3
XFILLER_1_175 VGND VGND VPWR VPWR sky130_fd_sc_hd__decap_3
XFILLER_77_411 VGND VGND VPWR VPWR sky130_fd_sc_hd__fill_1
XFILLER_49_124 VGND VGND VPWR VPWR sky130_fd_sc_hd__decap_3
XFILLER_49_157 VGND VGND VPWR VPWR sky130_fd_sc_hd__decap_3
XFILLER_77_433 VGND VGND VPWR VPWR sky130_fd_sc_hd__decap_3
XFILLER_18_500 VGND VGND VPWR VPWR sky130_fd_sc_hd__decap_3
XFILLER_37_308 VGND VGND VPWR VPWR sky130_fd_sc_hd__decap_3
XFILLER_65_617 VGND VGND VPWR VPWR sky130_fd_sc_hd__decap_3
XFILLER_77_499 VGND VGND VPWR VPWR sky130_fd_sc_hd__decap_3
XTAP_TAPCELL_ROW_86_1220 VGND VPWR sky130_fd_sc_hd__tapvpwrvgnd_1
XFILLER_18_555 VGND VGND VPWR VPWR sky130_fd_sc_hd__fill_2
XTAP_TAPCELL_ROW_56_881 VGND VPWR sky130_fd_sc_hd__tapvpwrvgnd_1
XTAP_TAPCELL_ROW_28_561 VGND VPWR sky130_fd_sc_hd__tapvpwrvgnd_1
XFILLER_72_193 VGND VGND VPWR VPWR sky130_fd_sc_hd__decap_3
XFILLER_13_271 VGND VGND VPWR VPWR sky130_fd_sc_hd__decap_3
XFILLER_41_591 VGND VGND VPWR VPWR sky130_fd_sc_hd__decap_3
XFILLER_9_231 VGND VGND VPWR VPWR sky130_fd_sc_hd__decap_3
XFILLER_9_220 VGND VGND VPWR VPWR sky130_fd_sc_hd__decap_3
XFILLER_70_91 VGND VGND VPWR VPWR sky130_fd_sc_hd__fill_1
Xclkload12 _7348_/CLK VGND VGND VPWR VPWR clkload12/Y sky130_fd_sc_hd__clkinv_2
Xclkload23 _6968_/CLK VGND VGND VPWR VPWR clkload23/X sky130_fd_sc_hd__clkbuf_8
Xclkload34 _7362_/CLK VGND VGND VPWR VPWR clkload34/X sky130_fd_sc_hd__clkbuf_1
X_3591_ _4376_/A _3591_/B _3591_/C _3586_/D VGND VGND VPWR VPWR _3591_/Y sky130_fd_sc_hd__nor4b_2
XFILLER_5_481 VGND VGND VPWR VPWR sky130_fd_sc_hd__decap_3
XFILLER_102_508 VGND VGND VPWR VPWR sky130_fd_sc_hd__decap_3
X_7000_ _7269_/CLK _7000_/D _6280_/Y VGND VGND VPWR VPWR _7000_/Q sky130_fd_sc_hd__dfrtp_2
X_4212_ _7324_/Q _3975_/S _4348_/B1 _7132_/Q VGND VGND VPWR VPWR _4212_/X sky130_fd_sc_hd__a22o_2
XFILLER_68_400 VGND VGND VPWR VPWR sky130_fd_sc_hd__fill_2
X_5192_ _5192_/A _5207_/B VGND VGND VPWR VPWR _7232_/D sky130_fd_sc_hd__and2_2
X_4143_ _4845_/A _4140_/X _4142_/X VGND VGND VPWR VPWR _4143_/X sky130_fd_sc_hd__a21o_2
XFILLER_56_639 VGND VGND VPWR VPWR sky130_fd_sc_hd__decap_3
XFILLER_68_466 VGND VGND VPWR VPWR sky130_fd_sc_hd__fill_2
XFILLER_68_477 VGND VGND VPWR VPWR sky130_fd_sc_hd__fill_2
X_4074_ _7083_/Q _4102_/B _4432_/B1 _4073_/X VGND VGND VPWR VPWR _4451_/A sky130_fd_sc_hd__o211ai_2
XFILLER_95_296 VGND VGND VPWR VPWR sky130_fd_sc_hd__fill_2
XFILLER_24_558 VGND VGND VPWR VPWR sky130_fd_sc_hd__decap_3
XFILLER_51_377 VGND VGND VPWR VPWR sky130_fd_sc_hd__decap_3
X_6715_ _6943_/CLK _6715_/D VGND VGND VPWR VPWR _6715_/Q sky130_fd_sc_hd__dfxtp_2
X_4976_ _6992_/Q _5001_/A _6993_/Q VGND VGND VPWR VPWR _4977_/B sky130_fd_sc_hd__a21oi_2
XFILLER_32_580 VGND VGND VPWR VPWR sky130_fd_sc_hd__decap_3
X_3927_ _3927_/A1 _3926_/X _5104_/A VGND VGND VPWR VPWR _3927_/X sky130_fd_sc_hd__a21o_2
Xclkload6 clkload6/A VGND VGND VPWR VPWR clkload6/X sky130_fd_sc_hd__clkbuf_1
X_6646_ _6646_/A VGND VGND VPWR VPWR _6646_/Y sky130_fd_sc_hd__inv_2
X_3858_ _6698_/Q _3911_/A2 _3665_/X _6876_/Q VGND VGND VPWR VPWR _3858_/X sky130_fd_sc_hd__a22o_2
X_6577_ _6613_/A VGND VGND VPWR VPWR _6577_/Y sky130_fd_sc_hd__inv_2
X_3789_ _3728_/Y _3781_/X _3783_/X _3725_/X _3788_/X VGND VGND VPWR VPWR _3789_/X
+ sky130_fd_sc_hd__a221o_2
XFILLER_105_302 VGND VGND VPWR VPWR sky130_fd_sc_hd__decap_3
XFILLER_105_368 VGND VGND VPWR VPWR sky130_fd_sc_hd__fill_2
XFILLER_59_422 VGND VGND VPWR VPWR sky130_fd_sc_hd__fill_2
XFILLER_78_219 VGND VGND VPWR VPWR sky130_fd_sc_hd__decap_3
XFILLER_59_455 VGND VGND VPWR VPWR sky130_fd_sc_hd__decap_3
XFILLER_86_230 VGND VGND VPWR VPWR sky130_fd_sc_hd__decap_3
X_7129_ _7352_/CLK _7129_/D _6409_/Y VGND VGND VPWR VPWR _7129_/Q sky130_fd_sc_hd__dfrtp_2
XTAP_TAPCELL_ROW_70_1043 VGND VPWR sky130_fd_sc_hd__tapvpwrvgnd_1
XFILLER_19_319 VGND VGND VPWR VPWR sky130_fd_sc_hd__decap_3
XFILLER_47_617 VGND VGND VPWR VPWR sky130_fd_sc_hd__decap_3
XFILLER_86_274 VGND VGND VPWR VPWR sky130_fd_sc_hd__decap_3
XFILLER_46_127 VGND VGND VPWR VPWR sky130_fd_sc_hd__decap_3
XFILLER_59_499 VGND VGND VPWR VPWR sky130_fd_sc_hd__decap_3
XFILLER_39_190 VGND VGND VPWR VPWR sky130_fd_sc_hd__decap_3
XFILLER_82_480 VGND VGND VPWR VPWR sky130_fd_sc_hd__decap_3
XFILLER_42_333 VGND VGND VPWR VPWR sky130_fd_sc_hd__decap_3
XFILLER_54_193 VGND VGND VPWR VPWR sky130_fd_sc_hd__decap_3
XFILLER_70_631 VGND VGND VPWR VPWR sky130_fd_sc_hd__decap_3
XTAP_TAPCELL_ROW_53_840 VGND VPWR sky130_fd_sc_hd__tapvpwrvgnd_1
XTAP_TAPCELL_ROW_25_520 VGND VPWR sky130_fd_sc_hd__tapvpwrvgnd_1
XTAP_TAPCELL_ROW_81_1161 VGND VPWR sky130_fd_sc_hd__tapvpwrvgnd_1
XFILLER_30_539 VGND VGND VPWR VPWR sky130_fd_sc_hd__fill_1
XFILLER_10_230 VGND VGND VPWR VPWR sky130_fd_sc_hd__decap_3
XFILLER_10_241 VGND VGND VPWR VPWR sky130_fd_sc_hd__decap_3
XFILLER_10_274 VGND VGND VPWR VPWR sky130_fd_sc_hd__decap_3
XFILLER_6_212 VGND VGND VPWR VPWR sky130_fd_sc_hd__decap_3
XFILLER_6_223 VGND VGND VPWR VPWR sky130_fd_sc_hd__decap_3
XFILLER_10_296 VGND VGND VPWR VPWR sky130_fd_sc_hd__decap_3
XFILLER_6_278 VGND VGND VPWR VPWR sky130_fd_sc_hd__fill_1
XFILLER_2_462 VGND VGND VPWR VPWR sky130_fd_sc_hd__fill_1
XTAP_TAPCELL_ROW_92_1290 VGND VPWR sky130_fd_sc_hd__tapvpwrvgnd_1
XFILLER_38_606 VGND VGND VPWR VPWR sky130_fd_sc_hd__decap_3
XFILLER_77_252 VGND VGND VPWR VPWR sky130_fd_sc_hd__decap_3
XFILLER_92_200 VGND VGND VPWR VPWR sky130_fd_sc_hd__decap_3
XFILLER_37_138 VGND VGND VPWR VPWR sky130_fd_sc_hd__decap_3
XFILLER_38_639 VGND VGND VPWR VPWR sky130_fd_sc_hd__decap_3
XFILLER_65_436 VGND VGND VPWR VPWR sky130_fd_sc_hd__fill_2
XFILLER_92_222 VGND VGND VPWR VPWR sky130_fd_sc_hd__decap_3
XFILLER_45_160 VGND VGND VPWR VPWR sky130_fd_sc_hd__decap_3
XFILLER_61_620 VGND VGND VPWR VPWR sky130_fd_sc_hd__decap_3
XFILLER_92_299 VGND VGND VPWR VPWR sky130_fd_sc_hd__decap_3
XFILLER_33_322 VGND VGND VPWR VPWR sky130_fd_sc_hd__decap_3
XFILLER_45_182 VGND VGND VPWR VPWR sky130_fd_sc_hd__decap_3
X_4830_ _4646_/Y _4827_/A _4829_/Y VGND VGND VPWR VPWR _4830_/X sky130_fd_sc_hd__o21a_2
XFILLER_60_141 VGND VGND VPWR VPWR sky130_fd_sc_hd__decap_3
XFILLER_60_152 VGND VGND VPWR VPWR sky130_fd_sc_hd__decap_3
XFILLER_14_580 VGND VGND VPWR VPWR sky130_fd_sc_hd__decap_3
XFILLER_21_539 VGND VGND VPWR VPWR sky130_fd_sc_hd__decap_3
X_4761_ _4762_/B _4761_/B _4761_/C VGND VGND VPWR VPWR _4761_/Y sky130_fd_sc_hd__nand3_2
X_6500_ _6628_/A VGND VGND VPWR VPWR _6500_/Y sky130_fd_sc_hd__inv_2
X_4692_ _7006_/Q _4749_/B VGND VGND VPWR VPWR _4750_/B sky130_fd_sc_hd__and2_2
X_3712_ _3746_/B VGND VGND VPWR VPWR _3741_/B sky130_fd_sc_hd__inv_2
X_6431_ _6625_/A VGND VGND VPWR VPWR _6431_/Y sky130_fd_sc_hd__inv_2
XTAP_TAPCELL_ROW_31_589 VGND VPWR sky130_fd_sc_hd__tapvpwrvgnd_1
X_6362_ _6364_/A VGND VGND VPWR VPWR _6362_/Y sky130_fd_sc_hd__inv_2
X_3574_ _7348_/Q _4285_/B1 _3573_/X _4248_/A VGND VGND VPWR VPWR _3574_/X sky130_fd_sc_hd__a211o_2
X_6293_ _6602_/A VGND VGND VPWR VPWR _6293_/Y sky130_fd_sc_hd__inv_2
XFILLER_102_327 VGND VGND VPWR VPWR sky130_fd_sc_hd__decap_3
XFILLER_88_539 VGND VGND VPWR VPWR sky130_fd_sc_hd__decap_3
XFILLER_68_230 VGND VGND VPWR VPWR sky130_fd_sc_hd__decap_3
X_5175_ _5175_/A _5186_/B VGND VGND VPWR VPWR _7240_/D sky130_fd_sc_hd__and2_2
XFILLER_29_617 VGND VGND VPWR VPWR sky130_fd_sc_hd__decap_3
X_4126_ _4126_/A _4125_/X VGND VGND VPWR VPWR _4890_/B sky130_fd_sc_hd__or2b_2
XFILLER_96_583 VGND VGND VPWR VPWR sky130_fd_sc_hd__decap_3
XFILLER_83_211 VGND VGND VPWR VPWR sky130_fd_sc_hd__decap_3
X_4057_ _7308_/Q _4488_/S _4437_/B1 _7372_/Q _4429_/C1 VGND VGND VPWR VPWR _4057_/X
+ sky130_fd_sc_hd__a221o_2
XTAP_TAPCELL_ROW_39_678 VGND VPWR sky130_fd_sc_hd__tapvpwrvgnd_1
XFILLER_36_171 VGND VGND VPWR VPWR sky130_fd_sc_hd__decap_3
XFILLER_43_108 VGND VGND VPWR VPWR sky130_fd_sc_hd__decap_3
XFILLER_43_119 VGND VGND VPWR VPWR sky130_fd_sc_hd__decap_3
XFILLER_83_277 VGND VGND VPWR VPWR sky130_fd_sc_hd__decap_3
XFILLER_83_299 VGND VGND VPWR VPWR sky130_fd_sc_hd__decap_3
XFILLER_101_12 VGND VGND VPWR VPWR sky130_fd_sc_hd__decap_3
XFILLER_52_642 VGND VGND VPWR VPWR sky130_fd_sc_hd__fill_2
XFILLER_64_491 VGND VGND VPWR VPWR sky130_fd_sc_hd__fill_1
XTAP_TAPCELL_ROW_104_1426 VGND VPWR sky130_fd_sc_hd__tapvpwrvgnd_1
XFILLER_12_528 VGND VGND VPWR VPWR sky130_fd_sc_hd__decap_3
XFILLER_51_152 VGND VGND VPWR VPWR sky130_fd_sc_hd__decap_3
XTAP_TAPCELL_ROW_50_810 VGND VPWR sky130_fd_sc_hd__tapvpwrvgnd_1
XFILLER_12_539 VGND VGND VPWR VPWR sky130_fd_sc_hd__decap_3
X_4959_ _6993_/Q _4958_/Y _6994_/Q VGND VGND VPWR VPWR _4960_/C sky130_fd_sc_hd__a21oi_2
XFILLER_20_583 VGND VGND VPWR VPWR sky130_fd_sc_hd__decap_3
X_6629_ _6630_/A VGND VGND VPWR VPWR _6629_/Y sky130_fd_sc_hd__inv_2
XFILLER_105_110 VGND VGND VPWR VPWR sky130_fd_sc_hd__fill_2
XFILLER_106_622 VGND VGND VPWR VPWR sky130_fd_sc_hd__decap_3
XFILLER_105_121 VGND VGND VPWR VPWR sky130_fd_sc_hd__fill_1
XFILLER_3_237 VGND VGND VPWR VPWR sky130_fd_sc_hd__decap_3
XFILLER_3_259 VGND VGND VPWR VPWR sky130_fd_sc_hd__decap_3
XFILLER_79_517 VGND VGND VPWR VPWR sky130_fd_sc_hd__decap_3
XFILLER_86_46 VGND VGND VPWR VPWR sky130_fd_sc_hd__decap_3
XFILLER_59_263 VGND VGND VPWR VPWR sky130_fd_sc_hd__decap_3
XFILLER_87_561 VGND VGND VPWR VPWR sky130_fd_sc_hd__decap_3
XFILLER_101_393 VGND VGND VPWR VPWR sky130_fd_sc_hd__decap_3
XFILLER_74_200 VGND VGND VPWR VPWR sky130_fd_sc_hd__decap_3
XFILLER_74_222 VGND VGND VPWR VPWR sky130_fd_sc_hd__fill_1
XFILLER_19_149 VGND VGND VPWR VPWR sky130_fd_sc_hd__decap_3
XFILLER_43_620 VGND VGND VPWR VPWR sky130_fd_sc_hd__decap_3
XFILLER_55_480 VGND VGND VPWR VPWR sky130_fd_sc_hd__decap_3
XFILLER_15_366 VGND VGND VPWR VPWR sky130_fd_sc_hd__decap_3
XFILLER_42_141 VGND VGND VPWR VPWR sky130_fd_sc_hd__decap_3
XFILLER_42_163 VGND VGND VPWR VPWR sky130_fd_sc_hd__decap_3
XFILLER_15_399 VGND VGND VPWR VPWR sky130_fd_sc_hd__decap_3
XFILLER_42_185 VGND VGND VPWR VPWR sky130_fd_sc_hd__decap_3
XFILLER_70_483 VGND VGND VPWR VPWR sky130_fd_sc_hd__decap_3
XFILLER_11_561 VGND VGND VPWR VPWR sky130_fd_sc_hd__decap_3
XFILLER_11_594 VGND VGND VPWR VPWR sky130_fd_sc_hd__decap_3
XFILLER_7_543 VGND VGND VPWR VPWR sky130_fd_sc_hd__decap_3
XFILLER_7_576 VGND VGND VPWR VPWR sky130_fd_sc_hd__decap_3
XFILLER_97_314 VGND VGND VPWR VPWR sky130_fd_sc_hd__decap_3
XFILLER_97_358 VGND VGND VPWR VPWR sky130_fd_sc_hd__decap_3
XFILLER_38_403 VGND VGND VPWR VPWR sky130_fd_sc_hd__decap_3
XFILLER_18_3 VGND VGND VPWR VPWR sky130_fd_sc_hd__fill_1
XFILLER_38_414 VGND VGND VPWR VPWR sky130_fd_sc_hd__decap_3
XFILLER_65_211 VGND VGND VPWR VPWR sky130_fd_sc_hd__decap_3
XFILLER_93_531 VGND VGND VPWR VPWR sky130_fd_sc_hd__decap_3
X_6980_ _7383_/CLK _6980_/D _6260_/Y VGND VGND VPWR VPWR _6980_/Q sky130_fd_sc_hd__dfrtp_2
XTAP_TAPCELL_ROW_0_218 VGND VPWR sky130_fd_sc_hd__tapvpwrvgnd_1
XFILLER_25_108 VGND VGND VPWR VPWR sky130_fd_sc_hd__decap_3
XFILLER_53_428 VGND VGND VPWR VPWR sky130_fd_sc_hd__decap_3
XFILLER_80_203 VGND VGND VPWR VPWR sky130_fd_sc_hd__decap_3
XFILLER_93_586 VGND VGND VPWR VPWR sky130_fd_sc_hd__decap_3
XTAP_TAPCELL_ROW_0_229 VGND VPWR sky130_fd_sc_hd__tapvpwrvgnd_1
XFILLER_18_171 VGND VGND VPWR VPWR sky130_fd_sc_hd__decap_3
XFILLER_34_620 VGND VGND VPWR VPWR sky130_fd_sc_hd__decap_3
XTAP_TAPCELL_ROW_64_968 VGND VPWR sky130_fd_sc_hd__tapvpwrvgnd_1
XTAP_TAPCELL_ROW_36_648 VGND VPWR sky130_fd_sc_hd__tapvpwrvgnd_1
XFILLER_33_163 VGND VGND VPWR VPWR sky130_fd_sc_hd__decap_3
X_4813_ _4813_/A _4813_/B VGND VGND VPWR VPWR _4813_/Y sky130_fd_sc_hd__nand2_2
X_4744_ _4938_/A _4744_/B VGND VGND VPWR VPWR _4744_/Y sky130_fd_sc_hd__nor2_2
XFILLER_107_419 VGND VGND VPWR VPWR sky130_fd_sc_hd__fill_2
X_4675_ _5138_/S _3469_/B _3564_/X _3449_/A _6984_/Q VGND VGND VPWR VPWR _5067_/B
+ sky130_fd_sc_hd__o2111a_2
X_7394_ _7397_/CLK _7394_/D _6674_/Y VGND VGND VPWR VPWR _7394_/Q sky130_fd_sc_hd__dfrtp_2
X_6414_ _6541_/A VGND VGND VPWR VPWR _6414_/Y sky130_fd_sc_hd__inv_2
X_3626_ _3616_/Y _3617_/X _3625_/X VGND VGND VPWR VPWR _3733_/C sky130_fd_sc_hd__a21oi_4
X_6345_ _6668_/A VGND VGND VPWR VPWR _6345_/Y sky130_fd_sc_hd__inv_2
X_3557_ _7221_/Q _3377_/X _4341_/B1 _7125_/Q _3556_/X VGND VGND VPWR VPWR _3557_/X
+ sky130_fd_sc_hd__a221o_2
XFILLER_88_303 VGND VGND VPWR VPWR sky130_fd_sc_hd__decap_3
X_6276_ _6278_/A VGND VGND VPWR VPWR _6276_/Y sky130_fd_sc_hd__inv_2
XTAP_TAPCELL_ROW_8_329 VGND VPWR sky130_fd_sc_hd__tapvpwrvgnd_1
XFILLER_102_124 VGND VGND VPWR VPWR sky130_fd_sc_hd__fill_1
XFILLER_103_647 VGND VGND VPWR VPWR sky130_fd_sc_hd__fill_1
XFILLER_88_336 VGND VGND VPWR VPWR sky130_fd_sc_hd__decap_3
X_5227_ _5227_/A1 _5225_/B _5655_/B VGND VGND VPWR VPWR _7215_/D sky130_fd_sc_hd__a21o_2
X_3488_ _7279_/Q _3488_/B VGND VGND VPWR VPWR _3488_/X sky130_fd_sc_hd__and2_2
XFILLER_84_531 VGND VGND VPWR VPWR sky130_fd_sc_hd__fill_1
XFILLER_17_609 VGND VGND VPWR VPWR sky130_fd_sc_hd__decap_3
XFILLER_56_244 VGND VGND VPWR VPWR sky130_fd_sc_hd__decap_3
XFILLER_84_542 VGND VGND VPWR VPWR sky130_fd_sc_hd__decap_3
XFILLER_84_564 VGND VGND VPWR VPWR sky130_fd_sc_hd__decap_3
X_5089_ _4764_/B _4315_/A _5086_/A _5101_/A _5088_/X VGND VGND VPWR VPWR _5089_/Y
+ sky130_fd_sc_hd__o221ai_2
X_4109_ _4376_/A _4141_/A _4141_/B _4142_/C VGND VGND VPWR VPWR _4109_/X sky130_fd_sc_hd__o31a_2
XFILLER_56_277 VGND VGND VPWR VPWR sky130_fd_sc_hd__fill_2
XFILLER_56_299 VGND VGND VPWR VPWR sky130_fd_sc_hd__decap_3
XFILLER_71_203 VGND VGND VPWR VPWR sky130_fd_sc_hd__decap_3
XFILLER_25_620 VGND VGND VPWR VPWR sky130_fd_sc_hd__decap_3
XFILLER_71_225 VGND VGND VPWR VPWR sky130_fd_sc_hd__decap_3
XFILLER_12_303 VGND VGND VPWR VPWR sky130_fd_sc_hd__decap_3
XFILLER_24_141 VGND VGND VPWR VPWR sky130_fd_sc_hd__decap_3
XFILLER_40_612 VGND VGND VPWR VPWR sky130_fd_sc_hd__decap_3
XFILLER_12_325 VGND VGND VPWR VPWR sky130_fd_sc_hd__decap_3
XFILLER_24_174 VGND VGND VPWR VPWR sky130_fd_sc_hd__decap_3
XFILLER_24_185 VGND VGND VPWR VPWR sky130_fd_sc_hd__decap_3
XFILLER_40_645 VGND VGND VPWR VPWR sky130_fd_sc_hd__decap_3
XFILLER_8_318 VGND VGND VPWR VPWR sky130_fd_sc_hd__decap_3
XFILLER_20_391 VGND VGND VPWR VPWR sky130_fd_sc_hd__decap_3
XFILLER_106_430 VGND VGND VPWR VPWR sky130_fd_sc_hd__decap_3
XFILLER_4_557 VGND VGND VPWR VPWR sky130_fd_sc_hd__decap_3
XFILLER_106_463 VGND VGND VPWR VPWR sky130_fd_sc_hd__fill_1
XFILLER_106_485 VGND VGND VPWR VPWR sky130_fd_sc_hd__decap_3
XFILLER_97_45 VGND VGND VPWR VPWR sky130_fd_sc_hd__fill_2
XFILLER_97_34 VGND VGND VPWR VPWR sky130_fd_sc_hd__decap_3
XFILLER_79_358 VGND VGND VPWR VPWR sky130_fd_sc_hd__decap_3
XFILLER_47_211 VGND VGND VPWR VPWR sky130_fd_sc_hd__decap_3
XFILLER_87_391 VGND VGND VPWR VPWR sky130_fd_sc_hd__fill_1
XFILLER_75_564 VGND VGND VPWR VPWR sky130_fd_sc_hd__fill_1
XFILLER_35_406 VGND VGND VPWR VPWR sky130_fd_sc_hd__decap_3
XFILLER_16_631 VGND VGND VPWR VPWR sky130_fd_sc_hd__decap_3
XFILLER_46_93 VGND VGND VPWR VPWR sky130_fd_sc_hd__fill_2
XFILLER_62_236 VGND VGND VPWR VPWR sky130_fd_sc_hd__decap_3
XFILLER_15_141 VGND VGND VPWR VPWR sky130_fd_sc_hd__decap_3
XFILLER_31_601 VGND VGND VPWR VPWR sky130_fd_sc_hd__decap_3
XFILLER_90_567 VGND VGND VPWR VPWR sky130_fd_sc_hd__decap_3
XFILLER_90_589 VGND VGND VPWR VPWR sky130_fd_sc_hd__decap_3
XTAP_TAPCELL_ROW_33_618 VGND VPWR sky130_fd_sc_hd__tapvpwrvgnd_1
XFILLER_31_623 VGND VGND VPWR VPWR sky130_fd_sc_hd__decap_3
XTAP_TAPCELL_ROW_61_938 VGND VPWR sky130_fd_sc_hd__tapvpwrvgnd_1
XFILLER_62_70 VGND VGND VPWR VPWR sky130_fd_sc_hd__decap_3
XFILLER_30_177 VGND VGND VPWR VPWR sky130_fd_sc_hd__decap_3
XFILLER_30_188 VGND VGND VPWR VPWR sky130_fd_sc_hd__decap_3
XTAP_TAPCELL_ROW_13_386 VGND VPWR sky130_fd_sc_hd__tapvpwrvgnd_1
XFILLER_7_362 VGND VGND VPWR VPWR sky130_fd_sc_hd__decap_3
X_4460_ _4460_/A _4460_/B VGND VGND VPWR VPWR _4460_/Y sky130_fd_sc_hd__nand2_2
X_4391_ _7401_/Q _4399_/A2 _4436_/B1 _7177_/Q _4390_/X VGND VGND VPWR VPWR _4391_/X
+ sky130_fd_sc_hd__a221o_2
X_3342_ _5670_/A _3561_/A VGND VGND VPWR VPWR _5118_/D sky130_fd_sc_hd__nand2b_4
XFILLER_98_645 VGND VGND VPWR VPWR sky130_fd_sc_hd__decap_3
XFILLER_98_634 VGND VGND VPWR VPWR sky130_fd_sc_hd__decap_3
XFILLER_97_122 VGND VGND VPWR VPWR sky130_fd_sc_hd__decap_3
XFILLER_97_155 VGND VGND VPWR VPWR sky130_fd_sc_hd__decap_3
XFILLER_100_639 VGND VGND VPWR VPWR sky130_fd_sc_hd__decap_3
XFILLER_38_211 VGND VGND VPWR VPWR sky130_fd_sc_hd__decap_3
XFILLER_78_380 VGND VGND VPWR VPWR sky130_fd_sc_hd__decap_3
Xhold1007 _7195_/Q VGND VGND VPWR VPWR _5270_/A0 sky130_fd_sc_hd__dlygate4sd3_1
Xhold1018 _7261_/Q VGND VGND VPWR VPWR _5012_/A0 sky130_fd_sc_hd__dlygate4sd3_1
Xhold1029 _7037_/Q VGND VGND VPWR VPWR _5583_/A0 sky130_fd_sc_hd__dlygate4sd3_1
X_5012_ _5012_/A0 _5011_/X _5159_/S VGND VGND VPWR VPWR _7261_/D sky130_fd_sc_hd__mux2_2
XFILLER_66_542 VGND VGND VPWR VPWR sky130_fd_sc_hd__fill_2
XFILLER_38_277 VGND VGND VPWR VPWR sky130_fd_sc_hd__decap_3
XFILLER_53_214 VGND VGND VPWR VPWR sky130_fd_sc_hd__fill_1
XFILLER_19_480 VGND VGND VPWR VPWR sky130_fd_sc_hd__decap_3
XFILLER_53_225 VGND VGND VPWR VPWR sky130_fd_sc_hd__decap_3
X_6963_ _6963_/CLK _6963_/D VGND VGND VPWR VPWR _6963_/Q sky130_fd_sc_hd__dfxtp_2
XTAP_TAPCELL_ROW_49_795 VGND VPWR sky130_fd_sc_hd__tapvpwrvgnd_1
XFILLER_22_601 VGND VGND VPWR VPWR sky130_fd_sc_hd__decap_3
XFILLER_34_450 VGND VGND VPWR VPWR sky130_fd_sc_hd__decap_3
XFILLER_53_258 VGND VGND VPWR VPWR sky130_fd_sc_hd__decap_3
X_6894_ _6965_/CLK _6894_/D VGND VGND VPWR VPWR _6894_/Q sky130_fd_sc_hd__dfxtp_2
XFILLER_22_634 VGND VGND VPWR VPWR sky130_fd_sc_hd__decap_3
XFILLER_34_472 VGND VGND VPWR VPWR sky130_fd_sc_hd__decap_3
XFILLER_34_483 VGND VGND VPWR VPWR sky130_fd_sc_hd__decap_3
XFILLER_21_122 VGND VGND VPWR VPWR sky130_fd_sc_hd__decap_3
XFILLER_22_645 VGND VGND VPWR VPWR sky130_fd_sc_hd__decap_3
XFILLER_42_29 VGND VGND VPWR VPWR sky130_fd_sc_hd__decap_3
XFILLER_21_166 VGND VGND VPWR VPWR sky130_fd_sc_hd__fill_2
X_4727_ _7007_/Q _4750_/B _4777_/A VGND VGND VPWR VPWR _4728_/B sky130_fd_sc_hd__o21a_2
X_4658_ _4658_/A _4658_/B VGND VGND VPWR VPWR _4658_/Y sky130_fd_sc_hd__nand2_2
Xhold830 _6966_/Q VGND VGND VPWR VPWR _6966_/D sky130_fd_sc_hd__dlygate4sd3_1
X_3609_ _5071_/A _5114_/A VGND VGND VPWR VPWR _3610_/B sky130_fd_sc_hd__nand2_2
XFILLER_107_22 VGND VGND VPWR VPWR sky130_fd_sc_hd__decap_3
XFILLER_89_601 VGND VGND VPWR VPWR sky130_fd_sc_hd__decap_3
X_7377_ _7383_/CLK _7377_/D _6657_/Y VGND VGND VPWR VPWR _7377_/Q sky130_fd_sc_hd__dfrtp_2
Xhold841 _7058_/Q VGND VGND VPWR VPWR _7058_/D sky130_fd_sc_hd__dlygate4sd3_1
Xhold852 _7115_/Q VGND VGND VPWR VPWR _7115_/D sky130_fd_sc_hd__dlygate4sd3_1
Xhold863 _7111_/Q VGND VGND VPWR VPWR _7111_/D sky130_fd_sc_hd__dlygate4sd3_1
Xmax_cap571 _6485_/A VGND VGND VPWR VPWR _6546_/A sky130_fd_sc_hd__clkbuf_2
Xmax_cap560 _4612_/A VGND VGND VPWR VPWR _4294_/A sky130_fd_sc_hd__buf_2
X_4589_ _4589_/A _4589_/B VGND VGND VPWR VPWR _7286_/D sky130_fd_sc_hd__and2_2
XFILLER_107_55 VGND VGND VPWR VPWR sky130_fd_sc_hd__fill_1
XFILLER_107_66 VGND VGND VPWR VPWR sky130_fd_sc_hd__decap_3
XFILLER_1_538 VGND VGND VPWR VPWR sky130_fd_sc_hd__decap_3
XFILLER_88_122 VGND VGND VPWR VPWR sky130_fd_sc_hd__decap_3
Xhold874 _7092_/Q VGND VGND VPWR VPWR _7092_/D sky130_fd_sc_hd__dlygate4sd3_1
Xhold885 _7070_/Q VGND VGND VPWR VPWR _7070_/D sky130_fd_sc_hd__dlygate4sd3_1
Xhold896 _7083_/Q VGND VGND VPWR VPWR _7083_/D sky130_fd_sc_hd__dlygate4sd3_1
X_6328_ _6686_/A VGND VGND VPWR VPWR _6328_/Y sky130_fd_sc_hd__inv_2
XFILLER_88_166 VGND VGND VPWR VPWR sky130_fd_sc_hd__decap_3
X_6259_ _6260_/A VGND VGND VPWR VPWR _6259_/Y sky130_fd_sc_hd__inv_2
XFILLER_103_499 VGND VGND VPWR VPWR sky130_fd_sc_hd__decap_3
XFILLER_29_211 VGND VGND VPWR VPWR sky130_fd_sc_hd__decap_3
XFILLER_76_328 VGND VGND VPWR VPWR sky130_fd_sc_hd__decap_3
XFILLER_57_542 VGND VGND VPWR VPWR sky130_fd_sc_hd__decap_3
XFILLER_29_255 VGND VGND VPWR VPWR sky130_fd_sc_hd__fill_2
XFILLER_29_277 VGND VGND VPWR VPWR sky130_fd_sc_hd__decap_3
XFILLER_29_288 VGND VGND VPWR VPWR sky130_fd_sc_hd__decap_3
XFILLER_44_203 VGND VGND VPWR VPWR sky130_fd_sc_hd__fill_2
XTAP_TAPCELL_ROW_67_1004 VGND VPWR sky130_fd_sc_hd__tapvpwrvgnd_1
XFILLER_44_225 VGND VGND VPWR VPWR sky130_fd_sc_hd__decap_3
XFILLER_44_247 VGND VGND VPWR VPWR sky130_fd_sc_hd__decap_3
XFILLER_83_47 VGND VGND VPWR VPWR sky130_fd_sc_hd__fill_1
XFILLER_84_383 VGND VGND VPWR VPWR sky130_fd_sc_hd__fill_2
XFILLER_25_461 VGND VGND VPWR VPWR sky130_fd_sc_hd__fill_2
XFILLER_72_589 VGND VGND VPWR VPWR sky130_fd_sc_hd__fill_1
XFILLER_13_612 VGND VGND VPWR VPWR sky130_fd_sc_hd__decap_3
XFILLER_13_623 VGND VGND VPWR VPWR sky130_fd_sc_hd__decap_3
XFILLER_16_85 VGND VGND VPWR VPWR sky130_fd_sc_hd__decap_3
XFILLER_25_472 VGND VGND VPWR VPWR sky130_fd_sc_hd__decap_3
XPHY_EDGE_ROW_11_Right_11 VGND VGND VPWR VPWR sky130_fd_sc_hd__decap_3
XFILLER_12_144 VGND VGND VPWR VPWR sky130_fd_sc_hd__decap_3
XFILLER_12_177 VGND VGND VPWR VPWR sky130_fd_sc_hd__decap_3
XFILLER_9_638 VGND VGND VPWR VPWR sky130_fd_sc_hd__decap_3
XFILLER_12_188 VGND VGND VPWR VPWR sky130_fd_sc_hd__decap_3
XFILLER_40_497 VGND VGND VPWR VPWR sky130_fd_sc_hd__decap_3
XFILLER_8_137 VGND VGND VPWR VPWR sky130_fd_sc_hd__decap_3
XTAP_TAPCELL_ROW_78_1133 VGND VPWR sky130_fd_sc_hd__tapvpwrvgnd_1
XTAP_TAPCELL_ROW_10_345 VGND VPWR sky130_fd_sc_hd__tapvpwrvgnd_1
XFILLER_4_365 VGND VGND VPWR VPWR sky130_fd_sc_hd__decap_3
XPHY_EDGE_ROW_20_Right_20 VGND VGND VPWR VPWR sky130_fd_sc_hd__decap_3
XFILLER_67_317 VGND VGND VPWR VPWR sky130_fd_sc_hd__decap_3
XFILLER_48_531 VGND VGND VPWR VPWR sky130_fd_sc_hd__fill_1
XFILLER_48_542 VGND VGND VPWR VPWR sky130_fd_sc_hd__decap_3
XFILLER_82_309 VGND VGND VPWR VPWR sky130_fd_sc_hd__decap_3
XFILLER_48_575 VGND VGND VPWR VPWR sky130_fd_sc_hd__fill_2
XFILLER_48_586 VGND VGND VPWR VPWR sky130_fd_sc_hd__fill_2
XFILLER_75_361 VGND VGND VPWR VPWR sky130_fd_sc_hd__fill_1
XTAP_TAPCELL_ROW_89_1262 VGND VPWR sky130_fd_sc_hd__tapvpwrvgnd_1
XFILLER_35_236 VGND VGND VPWR VPWR sky130_fd_sc_hd__fill_2
XFILLER_63_545 VGND VGND VPWR VPWR sky130_fd_sc_hd__fill_2
XFILLER_63_556 VGND VGND VPWR VPWR sky130_fd_sc_hd__decap_3
XFILLER_63_567 VGND VGND VPWR VPWR sky130_fd_sc_hd__fill_2
XFILLER_90_342 VGND VGND VPWR VPWR sky130_fd_sc_hd__decap_3
X_3960_ _3960_/A0 _4503_/A0 _3975_/S VGND VGND VPWR VPWR _7360_/D sky130_fd_sc_hd__mux2_2
XTAP_TAPCELL_ROW_46_765 VGND VPWR sky130_fd_sc_hd__tapvpwrvgnd_1
XTAP_TAPCELL_ROW_18_445 VGND VPWR sky130_fd_sc_hd__tapvpwrvgnd_1
XFILLER_16_472 VGND VGND VPWR VPWR sky130_fd_sc_hd__decap_3
XFILLER_16_483 VGND VGND VPWR VPWR sky130_fd_sc_hd__fill_1
XFILLER_50_239 VGND VGND VPWR VPWR sky130_fd_sc_hd__decap_3
X_3891_ _6951_/Q _3651_/Y _3925_/B1 _6957_/Q _3890_/X VGND VGND VPWR VPWR _3891_/X
+ sky130_fd_sc_hd__a221o_2
X_5630_ _5630_/A _5634_/B VGND VGND VPWR VPWR _7013_/D sky130_fd_sc_hd__and2_2
X_5561_ hold964/X _4777_/A _4695_/X VGND VGND VPWR VPWR _7054_/D sky130_fd_sc_hd__o21a_2
X_7300_ _7364_/CLK _7300_/D _6580_/Y VGND VGND VPWR VPWR _7300_/Q sky130_fd_sc_hd__dfrtp_2
XFILLER_7_181 VGND VGND VPWR VPWR sky130_fd_sc_hd__decap_3
X_7231_ _7361_/CLK _7231_/D _6511_/Y VGND VGND VPWR VPWR _7231_/Q sky130_fd_sc_hd__dfrtp_2
X_4443_ _4778_/A _4778_/B _4795_/A _4787_/A _4779_/A VGND VGND VPWR VPWR _4761_/B
+ sky130_fd_sc_hd__a2111o_2
X_7162_ _7280_/CLK _7162_/D _6442_/Y VGND VGND VPWR VPWR _7162_/Q sky130_fd_sc_hd__dfrtp_2
X_4374_ _4371_/Y _4224_/C _4373_/Y VGND VGND VPWR VPWR _4374_/X sky130_fd_sc_hd__o21a_2
X_7093_ _7349_/CLK _7093_/D _6373_/Y VGND VGND VPWR VPWR _7093_/Q sky130_fd_sc_hd__dfrtp_2
X_3325_ _3323_/X _3324_/X _5670_/A VGND VGND VPWR VPWR _3326_/B sky130_fd_sc_hd__a21oi_2
XPHY_EDGE_ROW_13_Left_122 VGND VGND VPWR VPWR sky130_fd_sc_hd__decap_3
XFILLER_98_464 VGND VGND VPWR VPWR sky130_fd_sc_hd__decap_3
XFILLER_100_403 VGND VGND VPWR VPWR sky130_fd_sc_hd__decap_3
XFILLER_98_497 VGND VGND VPWR VPWR sky130_fd_sc_hd__decap_3
XFILLER_85_136 VGND VGND VPWR VPWR sky130_fd_sc_hd__decap_3
XFILLER_26_203 VGND VGND VPWR VPWR sky130_fd_sc_hd__decap_3
XFILLER_66_350 VGND VGND VPWR VPWR sky130_fd_sc_hd__decap_3
XFILLER_85_169 VGND VGND VPWR VPWR sky130_fd_sc_hd__fill_1
XFILLER_26_236 VGND VGND VPWR VPWR sky130_fd_sc_hd__decap_3
XFILLER_81_331 VGND VGND VPWR VPWR sky130_fd_sc_hd__decap_3
XFILLER_54_589 VGND VGND VPWR VPWR sky130_fd_sc_hd__decap_3
X_6946_ clkload6/A _6946_/D VGND VGND VPWR VPWR _6946_/Q sky130_fd_sc_hd__dfxtp_2
XFILLER_41_228 VGND VGND VPWR VPWR sky130_fd_sc_hd__decap_3
XFILLER_53_28 VGND VGND VPWR VPWR sky130_fd_sc_hd__decap_3
X_6877_ clkload5/A _6877_/D VGND VGND VPWR VPWR _6877_/Q sky130_fd_sc_hd__dfxtp_2
XPHY_EDGE_ROW_22_Left_131 VGND VGND VPWR VPWR sky130_fd_sc_hd__decap_3
XFILLER_10_604 VGND VGND VPWR VPWR sky130_fd_sc_hd__decap_3
XFILLER_10_637 VGND VGND VPWR VPWR sky130_fd_sc_hd__decap_3
XFILLER_22_497 VGND VGND VPWR VPWR sky130_fd_sc_hd__fill_2
XFILLER_108_503 VGND VGND VPWR VPWR sky130_fd_sc_hd__fill_1
XFILLER_6_619 VGND VGND VPWR VPWR sky130_fd_sc_hd__decap_3
XFILLER_78_58 VGND VGND VPWR VPWR sky130_fd_sc_hd__decap_3
Xhold660 _6747_/Q VGND VGND VPWR VPWR _6747_/D sky130_fd_sc_hd__dlygate4sd3_1
Xhold671 _6823_/Q VGND VGND VPWR VPWR _6823_/D sky130_fd_sc_hd__dlygate4sd3_1
XPHY_EDGE_ROW_31_Left_140 VGND VGND VPWR VPWR sky130_fd_sc_hd__decap_3
XFILLER_89_464 VGND VGND VPWR VPWR sky130_fd_sc_hd__fill_1
Xhold682 _6945_/Q VGND VGND VPWR VPWR _6945_/D sky130_fd_sc_hd__dlygate4sd3_1
Xhold693 _6731_/Q VGND VGND VPWR VPWR _6731_/D sky130_fd_sc_hd__dlygate4sd3_1
XTAP_TAPCELL_ROW_73_1074 VGND VPWR sky130_fd_sc_hd__tapvpwrvgnd_1
XFILLER_76_103 VGND VGND VPWR VPWR sky130_fd_sc_hd__decap_3
XFILLER_89_486 VGND VGND VPWR VPWR sky130_fd_sc_hd__decap_3
XFILLER_103_296 VGND VGND VPWR VPWR sky130_fd_sc_hd__decap_3
XFILLER_76_147 VGND VGND VPWR VPWR sky130_fd_sc_hd__decap_3
XFILLER_64_309 VGND VGND VPWR VPWR sky130_fd_sc_hd__decap_3
XFILLER_17_225 VGND VGND VPWR VPWR sky130_fd_sc_hd__decap_3
XFILLER_91_139 VGND VGND VPWR VPWR sky130_fd_sc_hd__decap_3
XFILLER_32_206 VGND VGND VPWR VPWR sky130_fd_sc_hd__decap_3
XFILLER_32_239 VGND VGND VPWR VPWR sky130_fd_sc_hd__decap_3
XTAP_TAPCELL_ROW_43_724 VGND VPWR sky130_fd_sc_hd__tapvpwrvgnd_1
XTAP_TAPCELL_ROW_15_404 VGND VPWR sky130_fd_sc_hd__tapvpwrvgnd_1
XFILLER_13_431 VGND VGND VPWR VPWR sky130_fd_sc_hd__decap_3
XFILLER_9_402 VGND VGND VPWR VPWR sky130_fd_sc_hd__decap_3
XFILLER_9_468 VGND VGND VPWR VPWR sky130_fd_sc_hd__decap_3
XFILLER_9_446 VGND VGND VPWR VPWR sky130_fd_sc_hd__fill_2
XFILLER_5_641 VGND VGND VPWR VPWR sky130_fd_sc_hd__decap_3
XFILLER_99_206 VGND VGND VPWR VPWR sky130_fd_sc_hd__decap_3
XFILLER_4_195 VGND VGND VPWR VPWR sky130_fd_sc_hd__fill_1
XFILLER_4_88 VGND VGND VPWR VPWR sky130_fd_sc_hd__fill_2
XFILLER_68_80 VGND VGND VPWR VPWR sky130_fd_sc_hd__decap_3
XFILLER_95_401 VGND VGND VPWR VPWR sky130_fd_sc_hd__decap_3
XFILLER_95_423 VGND VGND VPWR VPWR sky130_fd_sc_hd__decap_3
XFILLER_67_125 VGND VGND VPWR VPWR sky130_fd_sc_hd__decap_3
XFILLER_67_158 VGND VGND VPWR VPWR sky130_fd_sc_hd__decap_3
X_4090_ _7302_/Q _4865_/S _4088_/X _4089_/X VGND VGND VPWR VPWR _4090_/X sky130_fd_sc_hd__a211o_2
XFILLER_48_350 VGND VGND VPWR VPWR sky130_fd_sc_hd__fill_2
XFILLER_48_361 VGND VGND VPWR VPWR sky130_fd_sc_hd__decap_3
XFILLER_95_489 VGND VGND VPWR VPWR sky130_fd_sc_hd__fill_2
XFILLER_63_320 VGND VGND VPWR VPWR sky130_fd_sc_hd__fill_2
XFILLER_36_578 VGND VGND VPWR VPWR sky130_fd_sc_hd__fill_1
XFILLER_63_353 VGND VGND VPWR VPWR sky130_fd_sc_hd__fill_2
Xplace331 _4351_/B1 VGND VGND VPWR VPWR _4267_/A2 sky130_fd_sc_hd__buf_2
Xplace320 _4190_/A2 VGND VGND VPWR VPWR _4422_/A2 sky130_fd_sc_hd__buf_2
X_6800_ clkload8/A _6800_/D VGND VGND VPWR VPWR _6800_/Q sky130_fd_sc_hd__dfxtp_2
XFILLER_36_589 VGND VGND VPWR VPWR sky130_fd_sc_hd__decap_3
XFILLER_90_172 VGND VGND VPWR VPWR sky130_fd_sc_hd__decap_3
Xplace364 _3558_/B VGND VGND VPWR VPWR _4305_/B sky130_fd_sc_hd__buf_2
Xplace353 _5159_/S VGND VGND VPWR VPWR _4998_/S sky130_fd_sc_hd__buf_2
Xplace342 _5072_/A VGND VGND VPWR VPWR _5006_/A1 sky130_fd_sc_hd__buf_2
X_4992_ _4987_/A _4991_/Y _4814_/A VGND VGND VPWR VPWR _4992_/Y sky130_fd_sc_hd__a21oi_2
Xplace375 _5138_/S VGND VGND VPWR VPWR _3864_/S sky130_fd_sc_hd__buf_2
Xplace386 _5225_/B VGND VGND VPWR VPWR _5186_/B sky130_fd_sc_hd__buf_2
Xplace397 _4429_/A2 VGND VGND VPWR VPWR _4488_/S sky130_fd_sc_hd__buf_2
X_6731_ _6968_/CLK _6731_/D VGND VGND VPWR VPWR _6731_/Q sky130_fd_sc_hd__dfxtp_2
X_3943_ _7368_/Q _4486_/A0 _3943_/S VGND VGND VPWR VPWR _7368_/D sky130_fd_sc_hd__mux2_2
X_6662_ _6662_/A VGND VGND VPWR VPWR _6662_/Y sky130_fd_sc_hd__inv_2
X_3874_ _3874_/A _3874_/B VGND VGND VPWR VPWR _3874_/X sky130_fd_sc_hd__or2_2
XFILLER_31_294 VGND VGND VPWR VPWR sky130_fd_sc_hd__decap_3
Xclkbuf_3_2__f_clk clkbuf_0_clk/X VGND VGND VPWR VPWR clkbuf_3_2__f_clk/X sky130_fd_sc_hd__clkbuf_16
X_5613_ _5613_/A _5622_/B VGND VGND VPWR VPWR _7021_/D sky130_fd_sc_hd__or2_2
X_6593_ _6635_/A VGND VGND VPWR VPWR _6593_/Y sky130_fd_sc_hd__inv_2
X_7214_ _7363_/CLK _7214_/D _6494_/Y VGND VGND VPWR VPWR _7214_/Q sky130_fd_sc_hd__dfrtp_2
X_4426_ _4446_/A _4426_/B VGND VGND VPWR VPWR _4813_/A sky130_fd_sc_hd__or2_2
X_7145_ _7406_/CLK _7145_/D _6425_/Y VGND VGND VPWR VPWR _7145_/Q sky130_fd_sc_hd__dfrtp_2
XFILLER_100_200 VGND VGND VPWR VPWR sky130_fd_sc_hd__decap_3
XFILLER_59_615 VGND VGND VPWR VPWR sky130_fd_sc_hd__fill_1
XFILLER_59_626 VGND VGND VPWR VPWR sky130_fd_sc_hd__decap_3
X_4357_ _4352_/X _4356_/X _4327_/A VGND VGND VPWR VPWR _4367_/C sky130_fd_sc_hd__o21ai_2
XFILLER_98_283 VGND VGND VPWR VPWR sky130_fd_sc_hd__decap_3
XFILLER_58_147 VGND VGND VPWR VPWR sky130_fd_sc_hd__decap_3
X_7076_ _7397_/CLK _7076_/D _6356_/Y VGND VGND VPWR VPWR _7076_/Q sky130_fd_sc_hd__dfrtp_2
X_4288_ _4394_/A _4288_/B _4288_/C _4288_/D VGND VGND VPWR VPWR _4288_/X sky130_fd_sc_hd__or4_4
X_3308_ _6981_/Q _3353_/B VGND VGND VPWR VPWR _5118_/C sky130_fd_sc_hd__nand2_2
XFILLER_98_294 VGND VGND VPWR VPWR sky130_fd_sc_hd__decap_3
XFILLER_104_23 VGND VGND VPWR VPWR sky130_fd_sc_hd__decap_3
XFILLER_46_309 VGND VGND VPWR VPWR sky130_fd_sc_hd__decap_3
XFILLER_58_169 VGND VGND VPWR VPWR sky130_fd_sc_hd__decap_3
XFILLER_27_545 VGND VGND VPWR VPWR sky130_fd_sc_hd__decap_3
XFILLER_27_567 VGND VGND VPWR VPWR sky130_fd_sc_hd__decap_3
XFILLER_14_206 VGND VGND VPWR VPWR sky130_fd_sc_hd__decap_3
XFILLER_54_397 VGND VGND VPWR VPWR sky130_fd_sc_hd__fill_2
XFILLER_81_172 VGND VGND VPWR VPWR sky130_fd_sc_hd__decap_3
XTAP_TAPCELL_ROW_107_1468 VGND VPWR sky130_fd_sc_hd__tapvpwrvgnd_1
XFILLER_14_239 VGND VGND VPWR VPWR sky130_fd_sc_hd__decap_3
Xfanout21 _6678_/A VGND VGND VPWR VPWR _6668_/A sky130_fd_sc_hd__buf_2
X_6929_ clkload4/A _6929_/D VGND VGND VPWR VPWR _6929_/Q sky130_fd_sc_hd__dfxtp_2
XFILLER_10_401 VGND VGND VPWR VPWR sky130_fd_sc_hd__decap_3
Xfanout32 _6594_/A VGND VGND VPWR VPWR _6635_/A sky130_fd_sc_hd__buf_2
Xfanout43 _6608_/A VGND VGND VPWR VPWR _6601_/A sky130_fd_sc_hd__buf_2
Xfanout54 fanout67/X VGND VGND VPWR VPWR _6680_/A sky130_fd_sc_hd__buf_2
Xfanout65 _6616_/A VGND VGND VPWR VPWR _6589_/A sky130_fd_sc_hd__clkdlybuf4s25_1
XFILLER_22_283 VGND VGND VPWR VPWR sky130_fd_sc_hd__decap_3
XFILLER_50_581 VGND VGND VPWR VPWR sky130_fd_sc_hd__decap_3
XFILLER_50_592 VGND VGND VPWR VPWR sky130_fd_sc_hd__fill_1
XFILLER_10_445 VGND VGND VPWR VPWR sky130_fd_sc_hd__decap_3
XFILLER_6_405 VGND VGND VPWR VPWR sky130_fd_sc_hd__decap_3
XFILLER_10_489 VGND VGND VPWR VPWR sky130_fd_sc_hd__decap_3
XTAP_TAPCELL_ROW_20_462 VGND VPWR sky130_fd_sc_hd__tapvpwrvgnd_1
XFILLER_108_355 VGND VGND VPWR VPWR sky130_fd_sc_hd__fill_1
XFILLER_108_377 VGND VGND VPWR VPWR sky130_fd_sc_hd__decap_3
XFILLER_89_57 VGND VGND VPWR VPWR sky130_fd_sc_hd__decap_3
XFILLER_108_399 VGND VGND VPWR VPWR sky130_fd_sc_hd__decap_3
XFILLER_2_622 VGND VGND VPWR VPWR sky130_fd_sc_hd__decap_3
XFILLER_1_143 VGND VGND VPWR VPWR sky130_fd_sc_hd__decap_3
XFILLER_104_583 VGND VGND VPWR VPWR sky130_fd_sc_hd__decap_3
XFILLER_89_261 VGND VGND VPWR VPWR sky130_fd_sc_hd__decap_3
XFILLER_49_136 VGND VGND VPWR VPWR sky130_fd_sc_hd__decap_3
XFILLER_38_61 VGND VGND VPWR VPWR sky130_fd_sc_hd__decap_3
XFILLER_49_169 VGND VGND VPWR VPWR sky130_fd_sc_hd__decap_3
XFILLER_65_629 VGND VGND VPWR VPWR sky130_fd_sc_hd__decap_3
XFILLER_77_467 VGND VGND VPWR VPWR sky130_fd_sc_hd__decap_3
XFILLER_92_404 VGND VGND VPWR VPWR sky130_fd_sc_hd__decap_3
XFILLER_18_512 VGND VGND VPWR VPWR sky130_fd_sc_hd__fill_2
XFILLER_18_523 VGND VGND VPWR VPWR sky130_fd_sc_hd__fill_1
XFILLER_92_426 VGND VGND VPWR VPWR sky130_fd_sc_hd__decap_3
XFILLER_92_459 VGND VGND VPWR VPWR sky130_fd_sc_hd__decap_3
XTAP_TAPCELL_ROW_86_1221 VGND VPWR sky130_fd_sc_hd__tapvpwrvgnd_1
XFILLER_18_578 VGND VGND VPWR VPWR sky130_fd_sc_hd__decap_3
Xhold1190 _7342_/Q VGND VGND VPWR VPWR _4474_/A0 sky130_fd_sc_hd__dlygate4sd3_1
XTAP_TAPCELL_ROW_28_551 VGND VPWR sky130_fd_sc_hd__tapvpwrvgnd_1
XFILLER_18_589 VGND VGND VPWR VPWR sky130_fd_sc_hd__decap_3
XFILLER_33_515 VGND VGND VPWR VPWR sky130_fd_sc_hd__decap_3
XFILLER_45_364 VGND VGND VPWR VPWR sky130_fd_sc_hd__decap_3
XFILLER_45_386 VGND VGND VPWR VPWR sky130_fd_sc_hd__decap_3
XFILLER_72_150 VGND VGND VPWR VPWR sky130_fd_sc_hd__fill_1
XFILLER_72_161 VGND VGND VPWR VPWR sky130_fd_sc_hd__fill_1
XFILLER_72_172 VGND VGND VPWR VPWR sky130_fd_sc_hd__decap_3
XTAP_TAPCELL_ROW_56_882 VGND VPWR sky130_fd_sc_hd__tapvpwrvgnd_1
XTAP_TAPCELL_ROW_28_562 VGND VPWR sky130_fd_sc_hd__tapvpwrvgnd_1
XFILLER_33_548 VGND VGND VPWR VPWR sky130_fd_sc_hd__decap_3
XFILLER_20_209 VGND VGND VPWR VPWR sky130_fd_sc_hd__decap_3
XFILLER_60_389 VGND VGND VPWR VPWR sky130_fd_sc_hd__decap_3
XFILLER_13_294 VGND VGND VPWR VPWR sky130_fd_sc_hd__decap_3
XFILLER_9_243 VGND VGND VPWR VPWR sky130_fd_sc_hd__decap_3
XFILLER_70_70 VGND VGND VPWR VPWR sky130_fd_sc_hd__fill_2
XFILLER_70_81 VGND VGND VPWR VPWR sky130_fd_sc_hd__decap_3
Xclkload13 _7350_/CLK VGND VGND VPWR VPWR clkload13/X sky130_fd_sc_hd__clkbuf_8
Xclkload24 _6965_/CLK VGND VGND VPWR VPWR clkload24/X sky130_fd_sc_hd__clkbuf_8
Xclkload35 _7276_/CLK VGND VGND VPWR VPWR clkload35/Y sky130_fd_sc_hd__inv_4
X_3590_ _4460_/A _3590_/B _3590_/C VGND VGND VPWR VPWR _3620_/C sky130_fd_sc_hd__and3_2
XTAP_TAPCELL_ROW_97_1350 VGND VPWR sky130_fd_sc_hd__tapvpwrvgnd_1
XFILLER_9_298 VGND VGND VPWR VPWR sky130_fd_sc_hd__fill_1
X_5260_ _5260_/A0 _4964_/X _5276_/S VGND VGND VPWR VPWR _7200_/D sky130_fd_sc_hd__mux2_2
XFILLER_5_493 VGND VGND VPWR VPWR sky130_fd_sc_hd__decap_3
XFILLER_87_209 VGND VGND VPWR VPWR sky130_fd_sc_hd__decap_3
X_4211_ _4633_/A _4143_/X _4206_/X _4384_/A _4210_/X VGND VGND VPWR VPWR _4778_/A
+ sky130_fd_sc_hd__a221oi_2
X_4142_ _4205_/A _4142_/B _4142_/C VGND VGND VPWR VPWR _4142_/X sky130_fd_sc_hd__and3_2
XFILLER_56_618 VGND VGND VPWR VPWR sky130_fd_sc_hd__decap_3
X_4073_ _7275_/Q _4437_/A2 _4070_/X _4072_/X VGND VGND VPWR VPWR _4073_/X sky130_fd_sc_hd__a211o_2
XFILLER_24_504 VGND VGND VPWR VPWR sky130_fd_sc_hd__decap_3
XFILLER_24_537 VGND VGND VPWR VPWR sky130_fd_sc_hd__decap_3
XFILLER_63_172 VGND VGND VPWR VPWR sky130_fd_sc_hd__decap_3
XFILLER_91_470 VGND VGND VPWR VPWR sky130_fd_sc_hd__decap_3
XFILLER_91_481 VGND VGND VPWR VPWR sky130_fd_sc_hd__decap_3
XFILLER_51_356 VGND VGND VPWR VPWR sky130_fd_sc_hd__decap_3
XFILLER_63_194 VGND VGND VPWR VPWR sky130_fd_sc_hd__fill_2
X_4975_ _4983_/A _4975_/B VGND VGND VPWR VPWR _4975_/Y sky130_fd_sc_hd__nand2_2
XFILLER_11_209 VGND VGND VPWR VPWR sky130_fd_sc_hd__decap_3
XFILLER_51_389 VGND VGND VPWR VPWR sky130_fd_sc_hd__decap_3
X_6714_ _7083_/CLK _6714_/D VGND VGND VPWR VPWR _6714_/Q sky130_fd_sc_hd__dfxtp_2
X_3926_ _6913_/Q _3926_/A2 _3926_/B1 _6777_/Q _3925_/X VGND VGND VPWR VPWR _3926_/X
+ sky130_fd_sc_hd__a221o_2
XFILLER_32_592 VGND VGND VPWR VPWR sky130_fd_sc_hd__decap_3
Xclkload7 clkload7/A VGND VGND VPWR VPWR clkload7/X sky130_fd_sc_hd__clkbuf_1
X_6645_ _6645_/A VGND VGND VPWR VPWR _6645_/Y sky130_fd_sc_hd__inv_2
X_3857_ hold947/X _3857_/A2 _3856_/X VGND VGND VPWR VPWR _7387_/D sky130_fd_sc_hd__a21o_2
X_6576_ _6608_/A VGND VGND VPWR VPWR _6576_/Y sky130_fd_sc_hd__inv_2
X_3788_ _3741_/X _3785_/X _3787_/X _3735_/X VGND VGND VPWR VPWR _3788_/X sky130_fd_sc_hd__a22o_2
XFILLER_105_314 VGND VGND VPWR VPWR sky130_fd_sc_hd__fill_2
XFILLER_105_325 VGND VGND VPWR VPWR sky130_fd_sc_hd__fill_1
XFILLER_105_347 VGND VGND VPWR VPWR sky130_fd_sc_hd__decap_3
XFILLER_1_9 VGND VGND VPWR VPWR sky130_fd_sc_hd__decap_3
XFILLER_59_49 VGND VGND VPWR VPWR sky130_fd_sc_hd__decap_3
Xoutput540 _7007_/Q VGND VGND VPWR VPWR pc_out[30] sky130_fd_sc_hd__clkdlybuf4s25_1
X_4409_ _4425_/A _4409_/B VGND VGND VPWR VPWR _4411_/B sky130_fd_sc_hd__nand2_2
X_7128_ _7352_/CLK _7128_/D _6408_/Y VGND VGND VPWR VPWR _7128_/Q sky130_fd_sc_hd__dfrtp_2
XTAP_TAPCELL_ROW_70_1044 VGND VPWR sky130_fd_sc_hd__tapvpwrvgnd_1
XFILLER_101_564 VGND VGND VPWR VPWR sky130_fd_sc_hd__decap_3
XFILLER_47_607 VGND VGND VPWR VPWR sky130_fd_sc_hd__decap_3
XFILLER_47_629 VGND VGND VPWR VPWR sky130_fd_sc_hd__decap_3
XFILLER_86_253 VGND VGND VPWR VPWR sky130_fd_sc_hd__fill_2
X_7059_ _7382_/CLK _7059_/D _6339_/Y VGND VGND VPWR VPWR _7059_/Q sky130_fd_sc_hd__dfrtp_2
XFILLER_46_139 VGND VGND VPWR VPWR sky130_fd_sc_hd__fill_1
XFILLER_86_286 VGND VGND VPWR VPWR sky130_fd_sc_hd__decap_3
XFILLER_27_375 VGND VGND VPWR VPWR sky130_fd_sc_hd__decap_3
XFILLER_42_301 VGND VGND VPWR VPWR sky130_fd_sc_hd__decap_3
XFILLER_61_109 VGND VGND VPWR VPWR sky130_fd_sc_hd__decap_3
XFILLER_70_643 VGND VGND VPWR VPWR sky130_fd_sc_hd__fill_1
XFILLER_82_492 VGND VGND VPWR VPWR sky130_fd_sc_hd__fill_2
XTAP_TAPCELL_ROW_53_841 VGND VPWR sky130_fd_sc_hd__tapvpwrvgnd_1
XTAP_TAPCELL_ROW_25_521 VGND VPWR sky130_fd_sc_hd__tapvpwrvgnd_1
XFILLER_30_518 VGND VGND VPWR VPWR sky130_fd_sc_hd__decap_3
XFILLER_24_85 VGND VGND VPWR VPWR sky130_fd_sc_hd__decap_3
XTAP_TAPCELL_ROW_81_1162 VGND VPWR sky130_fd_sc_hd__tapvpwrvgnd_1
XFILLER_10_253 VGND VGND VPWR VPWR sky130_fd_sc_hd__decap_3
XFILLER_108_152 VGND VGND VPWR VPWR sky130_fd_sc_hd__decap_3
XFILLER_2_474 VGND VGND VPWR VPWR sky130_fd_sc_hd__fill_2
XFILLER_104_380 VGND VGND VPWR VPWR sky130_fd_sc_hd__decap_3
XFILLER_77_220 VGND VGND VPWR VPWR sky130_fd_sc_hd__decap_3
XFILLER_77_231 VGND VGND VPWR VPWR sky130_fd_sc_hd__decap_3
XTAP_TAPCELL_ROW_92_1291 VGND VPWR sky130_fd_sc_hd__tapvpwrvgnd_1
XFILLER_1_12 VGND VGND VPWR VPWR sky130_fd_sc_hd__decap_3
XFILLER_38_618 VGND VGND VPWR VPWR sky130_fd_sc_hd__decap_3
XFILLER_37_128 VGND VGND VPWR VPWR sky130_fd_sc_hd__fill_1
XFILLER_92_212 VGND VGND VPWR VPWR sky130_fd_sc_hd__fill_2
XTAP_TAPCELL_ROW_5_290 VGND VPWR sky130_fd_sc_hd__tapvpwrvgnd_1
XFILLER_18_331 VGND VGND VPWR VPWR sky130_fd_sc_hd__decap_3
XFILLER_80_407 VGND VGND VPWR VPWR sky130_fd_sc_hd__decap_3
XFILLER_92_234 VGND VGND VPWR VPWR sky130_fd_sc_hd__decap_3
XFILLER_80_418 VGND VGND VPWR VPWR sky130_fd_sc_hd__fill_2
XFILLER_33_345 VGND VGND VPWR VPWR sky130_fd_sc_hd__decap_3
XFILLER_45_194 VGND VGND VPWR VPWR sky130_fd_sc_hd__decap_3
XFILLER_61_632 VGND VGND VPWR VPWR sky130_fd_sc_hd__decap_3
XFILLER_14_592 VGND VGND VPWR VPWR sky130_fd_sc_hd__decap_3
X_4760_ _4777_/A _4760_/B VGND VGND VPWR VPWR _4760_/Y sky130_fd_sc_hd__nand2_2
X_4691_ _7004_/Q _4665_/X _4804_/A _4757_/A VGND VGND VPWR VPWR _4749_/B sky130_fd_sc_hd__a31o_2
X_3711_ _3746_/A VGND VGND VPWR VPWR _3735_/A sky130_fd_sc_hd__inv_2
X_6430_ _6589_/A VGND VGND VPWR VPWR _6430_/Y sky130_fd_sc_hd__inv_2
X_3642_ _6718_/Q _6808_/Q _6896_/Q _6944_/Q _3991_/B _3665_/B VGND VGND VPWR VPWR
+ _3642_/X sky130_fd_sc_hd__mux4_2
X_6361_ _6364_/A VGND VGND VPWR VPWR _6361_/Y sky130_fd_sc_hd__inv_2
X_5312_ _5312_/A0 _4864_/X _5333_/S VGND VGND VPWR VPWR _7174_/D sky130_fd_sc_hd__mux2_2
X_3573_ _7316_/Q _3996_/S _4528_/B _7284_/Q VGND VGND VPWR VPWR _3573_/X sky130_fd_sc_hd__a22o_2
XPHY_EDGE_ROW_49_Right_49 VGND VGND VPWR VPWR sky130_fd_sc_hd__decap_3
X_6292_ _6612_/A VGND VGND VPWR VPWR _6292_/Y sky130_fd_sc_hd__inv_2
X_5243_ hold993/X _4822_/X _5274_/S VGND VGND VPWR VPWR _7208_/D sky130_fd_sc_hd__mux2_2
XFILLER_29_629 VGND VGND VPWR VPWR sky130_fd_sc_hd__decap_3
XFILLER_68_253 VGND VGND VPWR VPWR sky130_fd_sc_hd__decap_3
X_4125_ _4205_/A _4117_/B _4117_/C _4124_/B VGND VGND VPWR VPWR _4125_/X sky130_fd_sc_hd__a31o_2
XFILLER_28_139 VGND VGND VPWR VPWR sky130_fd_sc_hd__fill_1
XFILLER_83_223 VGND VGND VPWR VPWR sky130_fd_sc_hd__fill_1
XFILLER_45_18 VGND VGND VPWR VPWR sky130_fd_sc_hd__decap_3
X_4056_ _7340_/Q _3939_/S _4420_/B1 _7148_/Q VGND VGND VPWR VPWR _4056_/X sky130_fd_sc_hd__a22o_2
XPHY_EDGE_ROW_58_Right_58 VGND VGND VPWR VPWR sky130_fd_sc_hd__decap_3
XFILLER_36_150 VGND VGND VPWR VPWR sky130_fd_sc_hd__decap_3
XTAP_TAPCELL_ROW_39_679 VGND VPWR sky130_fd_sc_hd__tapvpwrvgnd_1
XFILLER_101_24 VGND VGND VPWR VPWR sky130_fd_sc_hd__decap_3
XFILLER_24_345 VGND VGND VPWR VPWR sky130_fd_sc_hd__decap_3
XFILLER_36_183 VGND VGND VPWR VPWR sky130_fd_sc_hd__decap_3
XFILLER_52_621 VGND VGND VPWR VPWR sky130_fd_sc_hd__decap_3
XTAP_TAPCELL_ROW_104_1427 VGND VPWR sky130_fd_sc_hd__tapvpwrvgnd_1
XFILLER_101_57 VGND VGND VPWR VPWR sky130_fd_sc_hd__fill_1
XFILLER_24_378 VGND VGND VPWR VPWR sky130_fd_sc_hd__decap_3
XFILLER_51_142 VGND VGND VPWR VPWR sky130_fd_sc_hd__decap_3
XFILLER_51_175 VGND VGND VPWR VPWR sky130_fd_sc_hd__decap_3
XFILLER_51_197 VGND VGND VPWR VPWR sky130_fd_sc_hd__decap_3
X_4958_ _4983_/B VGND VGND VPWR VPWR _4958_/Y sky130_fd_sc_hd__inv_2
XTAP_TAPCELL_ROW_50_811 VGND VPWR sky130_fd_sc_hd__tapvpwrvgnd_1
X_4889_ _4890_/B _4889_/B VGND VGND VPWR VPWR _4889_/Y sky130_fd_sc_hd__xnor2_2
X_3909_ hold985/X _3423_/A _3908_/X VGND VGND VPWR VPWR _7379_/D sky130_fd_sc_hd__a21o_2
X_6628_ _6628_/A VGND VGND VPWR VPWR _6628_/Y sky130_fd_sc_hd__inv_2
XFILLER_106_601 VGND VGND VPWR VPWR sky130_fd_sc_hd__decap_3
XFILLER_20_595 VGND VGND VPWR VPWR sky130_fd_sc_hd__decap_3
XPHY_EDGE_ROW_67_Right_67 VGND VGND VPWR VPWR sky130_fd_sc_hd__decap_3
XFILLER_106_634 VGND VGND VPWR VPWR sky130_fd_sc_hd__fill_2
XFILLER_3_216 VGND VGND VPWR VPWR sky130_fd_sc_hd__decap_3
X_6559_ _6559_/A VGND VGND VPWR VPWR _6559_/Y sky130_fd_sc_hd__inv_2
XFILLER_106_645 VGND VGND VPWR VPWR sky130_fd_sc_hd__decap_3
XPHY_EDGE_ROW_5_Left_114 VGND VGND VPWR VPWR sky130_fd_sc_hd__decap_3
XFILLER_105_166 VGND VGND VPWR VPWR sky130_fd_sc_hd__fill_2
XFILLER_79_529 VGND VGND VPWR VPWR sky130_fd_sc_hd__decap_3
XFILLER_86_69 VGND VGND VPWR VPWR sky130_fd_sc_hd__decap_3
XTAP_TAPCELL_ROW_58_900 VGND VPWR sky130_fd_sc_hd__tapvpwrvgnd_1
XFILLER_101_361 VGND VGND VPWR VPWR sky130_fd_sc_hd__decap_3
XFILLER_19_41 VGND VGND VPWR VPWR sky130_fd_sc_hd__decap_3
XFILLER_59_297 VGND VGND VPWR VPWR sky130_fd_sc_hd__decap_3
XPHY_EDGE_ROW_76_Right_76 VGND VGND VPWR VPWR sky130_fd_sc_hd__decap_3
XFILLER_28_640 VGND VGND VPWR VPWR sky130_fd_sc_hd__decap_3
XTAP_TAPCELL_ROW_2_260 VGND VPWR sky130_fd_sc_hd__tapvpwrvgnd_1
XFILLER_27_194 VGND VGND VPWR VPWR sky130_fd_sc_hd__fill_2
XFILLER_42_120 VGND VGND VPWR VPWR sky130_fd_sc_hd__decap_3
XFILLER_43_632 VGND VGND VPWR VPWR sky130_fd_sc_hd__decap_3
XFILLER_15_378 VGND VGND VPWR VPWR sky130_fd_sc_hd__fill_1
XFILLER_70_440 VGND VGND VPWR VPWR sky130_fd_sc_hd__decap_3
XFILLER_30_326 VGND VGND VPWR VPWR sky130_fd_sc_hd__decap_3
XFILLER_42_197 VGND VGND VPWR VPWR sky130_fd_sc_hd__decap_3
XFILLER_11_573 VGND VGND VPWR VPWR sky130_fd_sc_hd__decap_3
XFILLER_51_50 VGND VGND VPWR VPWR sky130_fd_sc_hd__decap_3
XFILLER_7_522 VGND VGND VPWR VPWR sky130_fd_sc_hd__decap_3
XPHY_EDGE_ROW_85_Right_85 VGND VGND VPWR VPWR sky130_fd_sc_hd__decap_3
XFILLER_7_555 VGND VGND VPWR VPWR sky130_fd_sc_hd__decap_3
XFILLER_7_588 VGND VGND VPWR VPWR sky130_fd_sc_hd__decap_3
XTAP_TAPCELL_ROW_94_1320 VGND VPWR sky130_fd_sc_hd__tapvpwrvgnd_1
XFILLER_97_337 VGND VGND VPWR VPWR sky130_fd_sc_hd__decap_3
XFILLER_97_326 VGND VGND VPWR VPWR sky130_fd_sc_hd__decap_3
XFILLER_2_293 VGND VGND VPWR VPWR sky130_fd_sc_hd__fill_2
XPHY_EDGE_ROW_94_Right_94 VGND VGND VPWR VPWR sky130_fd_sc_hd__decap_3
XFILLER_65_223 VGND VGND VPWR VPWR sky130_fd_sc_hd__fill_1
XFILLER_18_150 VGND VGND VPWR VPWR sky130_fd_sc_hd__decap_3
XFILLER_65_278 VGND VGND VPWR VPWR sky130_fd_sc_hd__fill_2
XFILLER_80_215 VGND VGND VPWR VPWR sky130_fd_sc_hd__decap_3
XFILLER_93_598 VGND VGND VPWR VPWR sky130_fd_sc_hd__decap_3
XTAP_TAPCELL_ROW_0_219 VGND VPWR sky130_fd_sc_hd__tapvpwrvgnd_1
XPHY_EDGE_ROW_69_Left_178 VGND VGND VPWR VPWR sky130_fd_sc_hd__decap_3
XFILLER_18_183 VGND VGND VPWR VPWR sky130_fd_sc_hd__decap_3
XFILLER_34_632 VGND VGND VPWR VPWR sky130_fd_sc_hd__decap_3
XFILLER_46_481 VGND VGND VPWR VPWR sky130_fd_sc_hd__decap_3
XFILLER_80_237 VGND VGND VPWR VPWR sky130_fd_sc_hd__decap_3
XTAP_TAPCELL_ROW_64_969 VGND VPWR sky130_fd_sc_hd__tapvpwrvgnd_1
XTAP_TAPCELL_ROW_36_649 VGND VPWR sky130_fd_sc_hd__tapvpwrvgnd_1
XFILLER_33_142 VGND VGND VPWR VPWR sky130_fd_sc_hd__fill_1
XFILLER_80_259 VGND VGND VPWR VPWR sky130_fd_sc_hd__fill_1
XFILLER_21_326 VGND VGND VPWR VPWR sky130_fd_sc_hd__decap_3
XFILLER_21_337 VGND VGND VPWR VPWR sky130_fd_sc_hd__decap_3
XFILLER_33_175 VGND VGND VPWR VPWR sky130_fd_sc_hd__fill_2
XFILLER_33_186 VGND VGND VPWR VPWR sky130_fd_sc_hd__decap_3
X_4812_ _4827_/A _4827_/B VGND VGND VPWR VPWR _4812_/Y sky130_fd_sc_hd__nor2_2
X_4743_ _4069_/Y _4081_/X _4741_/X _4742_/Y VGND VGND VPWR VPWR _4743_/X sky130_fd_sc_hd__a31o_2
X_6413_ _6609_/A VGND VGND VPWR VPWR _6413_/Y sky130_fd_sc_hd__inv_2
X_4674_ _6989_/Q _4677_/B VGND VGND VPWR VPWR _4674_/X sky130_fd_sc_hd__or2_2
XPHY_EDGE_ROW_78_Left_187 VGND VGND VPWR VPWR sky130_fd_sc_hd__decap_3
X_7393_ _7397_/CLK _7393_/D _6673_/Y VGND VGND VPWR VPWR _7393_/Q sky130_fd_sc_hd__dfrtp_2
X_3625_ _3618_/X _3619_/Y _3620_/X _3624_/X VGND VGND VPWR VPWR _3625_/X sky130_fd_sc_hd__a31o_2
X_6344_ _6344_/A VGND VGND VPWR VPWR _6344_/Y sky130_fd_sc_hd__inv_2
X_3556_ _4248_/A _3556_/B _3556_/C VGND VGND VPWR VPWR _3556_/X sky130_fd_sc_hd__or3_2
XFILLER_0_208 VGND VGND VPWR VPWR sky130_fd_sc_hd__decap_3
XFILLER_103_626 VGND VGND VPWR VPWR sky130_fd_sc_hd__decap_3
X_6275_ _6554_/A VGND VGND VPWR VPWR _6275_/Y sky130_fd_sc_hd__inv_2
XFILLER_88_348 VGND VGND VPWR VPWR sky130_fd_sc_hd__decap_3
X_3487_ _4217_/A1 _3469_/B _3449_/A _7247_/Q _3365_/A VGND VGND VPWR VPWR _3487_/X
+ sky130_fd_sc_hd__o2111a_2
XFILLER_102_147 VGND VGND VPWR VPWR sky130_fd_sc_hd__decap_3
XFILLER_69_551 VGND VGND VPWR VPWR sky130_fd_sc_hd__fill_1
XFILLER_56_201 VGND VGND VPWR VPWR sky130_fd_sc_hd__decap_3
X_5157_ _5157_/A0 _5156_/X _5159_/S VGND VGND VPWR VPWR _7248_/D sky130_fd_sc_hd__mux2_2
XFILLER_56_223 VGND VGND VPWR VPWR sky130_fd_sc_hd__decap_3
X_5088_ _5086_/A _4365_/X _5086_/X _5087_/Y _5020_/A VGND VGND VPWR VPWR _5088_/X
+ sky130_fd_sc_hd__a2111o_2
X_4108_ _4394_/A _4394_/B _4107_/X VGND VGND VPWR VPWR _4142_/C sky130_fd_sc_hd__or3b_2
XPHY_EDGE_ROW_87_Left_196 VGND VGND VPWR VPWR sky130_fd_sc_hd__decap_3
X_4039_ _4039_/A _4458_/A VGND VGND VPWR VPWR _4040_/B sky130_fd_sc_hd__and2_2
XFILLER_25_632 VGND VGND VPWR VPWR sky130_fd_sc_hd__decap_3
XFILLER_71_237 VGND VGND VPWR VPWR sky130_fd_sc_hd__decap_3
XFILLER_40_624 VGND VGND VPWR VPWR sky130_fd_sc_hd__decap_3
XFILLER_12_337 VGND VGND VPWR VPWR sky130_fd_sc_hd__decap_3
XFILLER_12_348 VGND VGND VPWR VPWR sky130_fd_sc_hd__decap_3
XFILLER_24_197 VGND VGND VPWR VPWR sky130_fd_sc_hd__decap_3
XFILLER_4_503 VGND VGND VPWR VPWR sky130_fd_sc_hd__decap_3
XFILLER_4_536 VGND VGND VPWR VPWR sky130_fd_sc_hd__fill_1
XFILLER_4_569 VGND VGND VPWR VPWR sky130_fd_sc_hd__decap_3
XFILLER_79_337 VGND VGND VPWR VPWR sky130_fd_sc_hd__decap_3
XFILLER_94_318 VGND VGND VPWR VPWR sky130_fd_sc_hd__decap_3
XFILLER_75_543 VGND VGND VPWR VPWR sky130_fd_sc_hd__decap_3
XFILLER_35_418 VGND VGND VPWR VPWR sky130_fd_sc_hd__decap_3
XFILLER_47_278 VGND VGND VPWR VPWR sky130_fd_sc_hd__fill_2
XFILLER_16_610 VGND VGND VPWR VPWR sky130_fd_sc_hd__decap_3
XFILLER_16_643 VGND VGND VPWR VPWR sky130_fd_sc_hd__fill_1
XFILLER_15_153 VGND VGND VPWR VPWR sky130_fd_sc_hd__fill_1
XTAP_TAPCELL_ROW_33_619 VGND VPWR sky130_fd_sc_hd__tapvpwrvgnd_1
XFILLER_15_164 VGND VGND VPWR VPWR sky130_fd_sc_hd__decap_3
XFILLER_31_613 VGND VGND VPWR VPWR sky130_fd_sc_hd__decap_3
XFILLER_31_635 VGND VGND VPWR VPWR sky130_fd_sc_hd__decap_3
XFILLER_43_484 VGND VGND VPWR VPWR sky130_fd_sc_hd__decap_3
XTAP_TAPCELL_ROW_61_939 VGND VPWR sky130_fd_sc_hd__tapvpwrvgnd_1
XFILLER_62_82 VGND VGND VPWR VPWR sky130_fd_sc_hd__fill_2
XFILLER_7_55 VGND VGND VPWR VPWR sky130_fd_sc_hd__fill_1
XTAP_TAPCELL_ROW_13_387 VGND VPWR sky130_fd_sc_hd__tapvpwrvgnd_1
XFILLER_7_77 VGND VGND VPWR VPWR sky130_fd_sc_hd__fill_1
X_4390_ _7241_/Q _4433_/B _3945_/S _7209_/Q VGND VGND VPWR VPWR _4390_/X sky130_fd_sc_hd__a22o_2
X_3410_ _7219_/Q _4307_/A2 _4532_/S _7032_/Q VGND VGND VPWR VPWR _3410_/X sky130_fd_sc_hd__a22o_2
X_3341_ _3341_/A VGND VGND VPWR VPWR _5642_/A sky130_fd_sc_hd__inv_2
XFILLER_3_591 VGND VGND VPWR VPWR sky130_fd_sc_hd__decap_3
XFILLER_30_3 VGND VGND VPWR VPWR sky130_fd_sc_hd__fill_2
XFILLER_97_167 VGND VGND VPWR VPWR sky130_fd_sc_hd__fill_1
XFILLER_85_318 VGND VGND VPWR VPWR sky130_fd_sc_hd__decap_3
Xhold1008 _7200_/Q VGND VGND VPWR VPWR _5260_/A0 sky130_fd_sc_hd__dlygate4sd3_1
Xhold1019 _7269_/Q VGND VGND VPWR VPWR _4879_/A0 sky130_fd_sc_hd__dlygate4sd3_1
X_5011_ _5061_/S _6991_/D _5010_/X VGND VGND VPWR VPWR _5011_/X sky130_fd_sc_hd__o21a_2
XFILLER_93_340 VGND VGND VPWR VPWR sky130_fd_sc_hd__decap_3
XFILLER_38_289 VGND VGND VPWR VPWR sky130_fd_sc_hd__decap_3
XFILLER_53_237 VGND VGND VPWR VPWR sky130_fd_sc_hd__decap_3
X_6962_ _6968_/CLK _6962_/D VGND VGND VPWR VPWR _6962_/Q sky130_fd_sc_hd__dfxtp_2
XTAP_TAPCELL_ROW_49_796 VGND VPWR sky130_fd_sc_hd__tapvpwrvgnd_1
XFILLER_81_568 VGND VGND VPWR VPWR sky130_fd_sc_hd__decap_3
X_6893_ _6943_/CLK _6893_/D VGND VGND VPWR VPWR _6893_/Q sky130_fd_sc_hd__dfxtp_2
XFILLER_22_613 VGND VGND VPWR VPWR sky130_fd_sc_hd__decap_3
XFILLER_61_270 VGND VGND VPWR VPWR sky130_fd_sc_hd__decap_3
XFILLER_21_145 VGND VGND VPWR VPWR sky130_fd_sc_hd__decap_3
XFILLER_61_281 VGND VGND VPWR VPWR sky130_fd_sc_hd__fill_2
XFILLER_21_189 VGND VGND VPWR VPWR sky130_fd_sc_hd__decap_3
X_4726_ _4832_/A _5655_/A _3670_/X _4467_/B VGND VGND VPWR VPWR _4726_/X sky130_fd_sc_hd__o211a_2
XFILLER_107_228 VGND VGND VPWR VPWR sky130_fd_sc_hd__fill_2
X_4657_ _4720_/A _4655_/X _4948_/A VGND VGND VPWR VPWR _4658_/B sky130_fd_sc_hd__a21oi_2
X_7376_ _7376_/CLK _7376_/D _6656_/Y VGND VGND VPWR VPWR _7376_/Q sky130_fd_sc_hd__dfrtp_2
Xhold820 _6831_/Q VGND VGND VPWR VPWR _6831_/D sky130_fd_sc_hd__dlygate4sd3_1
XFILLER_101_9 VGND VGND VPWR VPWR sky130_fd_sc_hd__decap_3
XFILLER_1_517 VGND VGND VPWR VPWR sky130_fd_sc_hd__decap_3
XFILLER_89_613 VGND VGND VPWR VPWR sky130_fd_sc_hd__decap_3
Xhold831 _6801_/Q VGND VGND VPWR VPWR _6801_/D sky130_fd_sc_hd__dlygate4sd3_1
Xhold842 _7098_/Q VGND VGND VPWR VPWR _7098_/D sky130_fd_sc_hd__dlygate4sd3_1
Xhold853 _7068_/Q VGND VGND VPWR VPWR _7068_/D sky130_fd_sc_hd__dlygate4sd3_1
Xhold864 _7113_/Q VGND VGND VPWR VPWR _7113_/D sky130_fd_sc_hd__dlygate4sd3_1
Xmax_cap572 _6640_/A VGND VGND VPWR VPWR _6602_/A sky130_fd_sc_hd__buf_2
X_6327_ _6686_/A VGND VGND VPWR VPWR _6327_/Y sky130_fd_sc_hd__inv_2
XFILLER_107_34 VGND VGND VPWR VPWR sky130_fd_sc_hd__decap_3
XFILLER_89_646 VGND VGND VPWR VPWR sky130_fd_sc_hd__fill_2
Xhold875 _7059_/Q VGND VGND VPWR VPWR _7059_/D sky130_fd_sc_hd__dlygate4sd3_1
Xhold886 _7060_/Q VGND VGND VPWR VPWR _7060_/D sky130_fd_sc_hd__dlygate4sd3_1
Xhold897 _7090_/Q VGND VGND VPWR VPWR _7090_/D sky130_fd_sc_hd__dlygate4sd3_1
X_3539_ _3544_/A _3544_/B VGND VGND VPWR VPWR _3547_/A sky130_fd_sc_hd__nand2_2
XFILLER_107_78 VGND VGND VPWR VPWR sky130_fd_sc_hd__decap_3
XFILLER_88_134 VGND VGND VPWR VPWR sky130_fd_sc_hd__decap_3
XPHY_EDGE_ROW_95_Left_204 VGND VGND VPWR VPWR sky130_fd_sc_hd__decap_3
XFILLER_69_370 VGND VGND VPWR VPWR sky130_fd_sc_hd__decap_3
XFILLER_88_178 VGND VGND VPWR VPWR sky130_fd_sc_hd__decap_3
X_5209_ _5209_/A _5223_/B VGND VGND VPWR VPWR _7224_/D sky130_fd_sc_hd__and2_2
XFILLER_29_223 VGND VGND VPWR VPWR sky130_fd_sc_hd__fill_1
XFILLER_29_234 VGND VGND VPWR VPWR sky130_fd_sc_hd__decap_3
XFILLER_83_26 VGND VGND VPWR VPWR sky130_fd_sc_hd__fill_1
XTAP_TAPCELL_ROW_67_1005 VGND VPWR sky130_fd_sc_hd__tapvpwrvgnd_1
XFILLER_44_259 VGND VGND VPWR VPWR sky130_fd_sc_hd__decap_3
XFILLER_13_635 VGND VGND VPWR VPWR sky130_fd_sc_hd__decap_3
XFILLER_25_495 VGND VGND VPWR VPWR sky130_fd_sc_hd__decap_3
XFILLER_52_292 VGND VGND VPWR VPWR sky130_fd_sc_hd__decap_3
XFILLER_9_617 VGND VGND VPWR VPWR sky130_fd_sc_hd__decap_3
XFILLER_9_606 VGND VGND VPWR VPWR sky130_fd_sc_hd__decap_3
XFILLER_12_156 VGND VGND VPWR VPWR sky130_fd_sc_hd__decap_3
XFILLER_4_300 VGND VGND VPWR VPWR sky130_fd_sc_hd__fill_1
XTAP_TAPCELL_ROW_78_1134 VGND VPWR sky130_fd_sc_hd__tapvpwrvgnd_1
XTAP_TAPCELL_ROW_10_346 VGND VPWR sky130_fd_sc_hd__tapvpwrvgnd_1
XFILLER_4_333 VGND VGND VPWR VPWR sky130_fd_sc_hd__fill_1
XFILLER_4_377 VGND VGND VPWR VPWR sky130_fd_sc_hd__fill_2
XFILLER_0_561 VGND VGND VPWR VPWR sky130_fd_sc_hd__decap_3
XFILLER_79_167 VGND VGND VPWR VPWR sky130_fd_sc_hd__fill_1
XFILLER_79_178 VGND VGND VPWR VPWR sky130_fd_sc_hd__decap_3
XFILLER_94_115 VGND VGND VPWR VPWR sky130_fd_sc_hd__decap_3
XFILLER_57_60 VGND VGND VPWR VPWR sky130_fd_sc_hd__decap_3
XFILLER_94_159 VGND VGND VPWR VPWR sky130_fd_sc_hd__decap_3
XTAP_TAPCELL_ROW_89_1263 VGND VPWR sky130_fd_sc_hd__tapvpwrvgnd_1
XFILLER_35_215 VGND VGND VPWR VPWR sky130_fd_sc_hd__decap_3
XFILLER_35_259 VGND VGND VPWR VPWR sky130_fd_sc_hd__fill_1
XFILLER_90_354 VGND VGND VPWR VPWR sky130_fd_sc_hd__decap_3
XFILLER_90_365 VGND VGND VPWR VPWR sky130_fd_sc_hd__decap_3
XTAP_TAPCELL_ROW_46_766 VGND VPWR sky130_fd_sc_hd__tapvpwrvgnd_1
XTAP_TAPCELL_ROW_18_446 VGND VPWR sky130_fd_sc_hd__tapvpwrvgnd_1
XFILLER_16_462 VGND VGND VPWR VPWR sky130_fd_sc_hd__fill_1
XFILLER_31_421 VGND VGND VPWR VPWR sky130_fd_sc_hd__decap_3
XFILLER_31_443 VGND VGND VPWR VPWR sky130_fd_sc_hd__fill_2
XFILLER_43_281 VGND VGND VPWR VPWR sky130_fd_sc_hd__decap_3
X_3890_ _6963_/Q _3661_/X _3893_/B1 _6945_/Q VGND VGND VPWR VPWR _3890_/X sky130_fd_sc_hd__a22o_2
XFILLER_31_476 VGND VGND VPWR VPWR sky130_fd_sc_hd__decap_3
XFILLER_7_193 VGND VGND VPWR VPWR sky130_fd_sc_hd__decap_3
X_7230_ _7362_/CLK _7230_/D _6510_/Y VGND VGND VPWR VPWR _7230_/Q sky130_fd_sc_hd__dfrtp_2
X_4442_ _4813_/A _4827_/A VGND VGND VPWR VPWR _4779_/A sky130_fd_sc_hd__or2_2
X_7161_ _7352_/CLK _7161_/D _6441_/Y VGND VGND VPWR VPWR _7161_/Q sky130_fd_sc_hd__dfrtp_2
X_4373_ _5018_/A _5018_/B VGND VGND VPWR VPWR _4373_/Y sky130_fd_sc_hd__nand2_2
XFILLER_98_421 VGND VGND VPWR VPWR sky130_fd_sc_hd__decap_3
XFILLER_98_410 VGND VGND VPWR VPWR sky130_fd_sc_hd__decap_3
X_7092_ _7349_/CLK _7092_/D _6372_/Y VGND VGND VPWR VPWR _7092_/Q sky130_fd_sc_hd__dfrtp_2
X_3324_ _6981_/Q _4467_/A _4696_/B VGND VGND VPWR VPWR _3324_/X sky130_fd_sc_hd__or3_2
XFILLER_58_318 VGND VGND VPWR VPWR sky130_fd_sc_hd__decap_3
XFILLER_85_148 VGND VGND VPWR VPWR sky130_fd_sc_hd__decap_3
XFILLER_39_554 VGND VGND VPWR VPWR sky130_fd_sc_hd__decap_3
XFILLER_26_215 VGND VGND VPWR VPWR sky130_fd_sc_hd__decap_3
XFILLER_93_181 VGND VGND VPWR VPWR sky130_fd_sc_hd__decap_3
XFILLER_26_259 VGND VGND VPWR VPWR sky130_fd_sc_hd__decap_3
XFILLER_54_579 VGND VGND VPWR VPWR sky130_fd_sc_hd__decap_3
X_6945_ _6963_/CLK _6945_/D VGND VGND VPWR VPWR _6945_/Q sky130_fd_sc_hd__dfxtp_2
XFILLER_81_387 VGND VGND VPWR VPWR sky130_fd_sc_hd__decap_3
XFILLER_22_421 VGND VGND VPWR VPWR sky130_fd_sc_hd__fill_1
XFILLER_34_281 VGND VGND VPWR VPWR sky130_fd_sc_hd__fill_1
X_6876_ clkload8/A _6876_/D VGND VGND VPWR VPWR _6876_/Q sky130_fd_sc_hd__dfxtp_2
XFILLER_10_616 VGND VGND VPWR VPWR sky130_fd_sc_hd__decap_3
XFILLER_22_465 VGND VGND VPWR VPWR sky130_fd_sc_hd__decap_3
XFILLER_108_526 VGND VGND VPWR VPWR sky130_fd_sc_hd__decap_3
XFILLER_5_119 VGND VGND VPWR VPWR sky130_fd_sc_hd__fill_1
X_4709_ _7002_/Q _7003_/Q _4826_/A VGND VGND VPWR VPWR _4801_/A sky130_fd_sc_hd__and3_2
XFILLER_89_432 VGND VGND VPWR VPWR sky130_fd_sc_hd__decap_3
X_7359_ _7364_/CLK _7359_/D _6639_/Y VGND VGND VPWR VPWR _7359_/Q sky130_fd_sc_hd__dfrtp_2
Xhold650 _6949_/Q VGND VGND VPWR VPWR _6949_/D sky130_fd_sc_hd__dlygate4sd3_1
Xhold661 _6846_/Q VGND VGND VPWR VPWR _6846_/D sky130_fd_sc_hd__dlygate4sd3_1
Xhold672 _6799_/Q VGND VGND VPWR VPWR _6799_/D sky130_fd_sc_hd__dlygate4sd3_1
Xhold683 _6929_/Q VGND VGND VPWR VPWR _6929_/D sky130_fd_sc_hd__dlygate4sd3_1
Xhold694 _6905_/Q VGND VGND VPWR VPWR _6905_/D sky130_fd_sc_hd__dlygate4sd3_1
XTAP_TAPCELL_ROW_73_1075 VGND VPWR sky130_fd_sc_hd__tapvpwrvgnd_1
XFILLER_1_369 VGND VGND VPWR VPWR sky130_fd_sc_hd__fill_2
XFILLER_49_318 VGND VGND VPWR VPWR sky130_fd_sc_hd__decap_3
XFILLER_49_329 VGND VGND VPWR VPWR sky130_fd_sc_hd__decap_3
XFILLER_77_638 VGND VGND VPWR VPWR sky130_fd_sc_hd__decap_3
XFILLER_76_126 VGND VGND VPWR VPWR sky130_fd_sc_hd__decap_3
XFILLER_45_502 VGND VGND VPWR VPWR sky130_fd_sc_hd__fill_2
XFILLER_17_204 VGND VGND VPWR VPWR sky130_fd_sc_hd__decap_3
XFILLER_17_237 VGND VGND VPWR VPWR sky130_fd_sc_hd__decap_3
XFILLER_72_321 VGND VGND VPWR VPWR sky130_fd_sc_hd__decap_3
XFILLER_84_181 VGND VGND VPWR VPWR sky130_fd_sc_hd__decap_3
XFILLER_45_557 VGND VGND VPWR VPWR sky130_fd_sc_hd__decap_3
XFILLER_13_410 VGND VGND VPWR VPWR sky130_fd_sc_hd__decap_3
XFILLER_32_218 VGND VGND VPWR VPWR sky130_fd_sc_hd__decap_3
XFILLER_60_527 VGND VGND VPWR VPWR sky130_fd_sc_hd__fill_2
XTAP_TAPCELL_ROW_43_725 VGND VPWR sky130_fd_sc_hd__tapvpwrvgnd_1
XTAP_TAPCELL_ROW_15_405 VGND VPWR sky130_fd_sc_hd__tapvpwrvgnd_1
XFILLER_13_443 VGND VGND VPWR VPWR sky130_fd_sc_hd__decap_3
XFILLER_25_281 VGND VGND VPWR VPWR sky130_fd_sc_hd__decap_3
XFILLER_60_549 VGND VGND VPWR VPWR sky130_fd_sc_hd__decap_3
XFILLER_43_51 VGND VGND VPWR VPWR sky130_fd_sc_hd__fill_1
XFILLER_9_414 VGND VGND VPWR VPWR sky130_fd_sc_hd__decap_3
XFILLER_5_620 VGND VGND VPWR VPWR sky130_fd_sc_hd__decap_3
XFILLER_107_581 VGND VGND VPWR VPWR sky130_fd_sc_hd__fill_1
XFILLER_4_163 VGND VGND VPWR VPWR sky130_fd_sc_hd__fill_1
XFILLER_68_627 VGND VGND VPWR VPWR sky130_fd_sc_hd__decap_3
XFILLER_48_395 VGND VGND VPWR VPWR sky130_fd_sc_hd__decap_3
XFILLER_51_505 VGND VGND VPWR VPWR sky130_fd_sc_hd__decap_3
XFILLER_63_332 VGND VGND VPWR VPWR sky130_fd_sc_hd__decap_3
Xplace321 _4260_/A2 VGND VGND VPWR VPWR _4190_/A2 sky130_fd_sc_hd__buf_2
Xplace310 _5020_/A VGND VGND VPWR VPWR _4814_/A sky130_fd_sc_hd__buf_2
XFILLER_90_151 VGND VGND VPWR VPWR sky130_fd_sc_hd__decap_3
Xplace354 _5063_/S VGND VGND VPWR VPWR _5159_/S sky130_fd_sc_hd__buf_2
Xplace343 _5114_/A VGND VGND VPWR VPWR _5072_/A sky130_fd_sc_hd__buf_2
Xplace332 _3407_/X VGND VGND VPWR VPWR _4351_/B1 sky130_fd_sc_hd__buf_2
X_6730_ clkload3/A _6730_/D VGND VGND VPWR VPWR _6730_/Q sky130_fd_sc_hd__dfxtp_2
X_4991_ _5004_/A _5004_/B _4988_/A VGND VGND VPWR VPWR _4991_/Y sky130_fd_sc_hd__a21oi_2
XFILLER_90_184 VGND VGND VPWR VPWR sky130_fd_sc_hd__decap_3
Xplace376 _3339_/Y VGND VGND VPWR VPWR _5138_/S sky130_fd_sc_hd__buf_2
Xplace387 _5225_/B VGND VGND VPWR VPWR _5223_/B sky130_fd_sc_hd__buf_2
Xplace398 _4244_/B VGND VGND VPWR VPWR _4429_/A2 sky130_fd_sc_hd__buf_2
Xplace365 _4347_/C1 VGND VGND VPWR VPWR _4429_/C1 sky130_fd_sc_hd__buf_2
XFILLER_31_262 VGND VGND VPWR VPWR sky130_fd_sc_hd__decap_3
X_6661_ _6667_/A VGND VGND VPWR VPWR _6661_/Y sky130_fd_sc_hd__inv_2
X_3873_ _3733_/X _3870_/X _3872_/X _3927_/A1 VGND VGND VPWR VPWR _3874_/B sky130_fd_sc_hd__a22o_2
XFILLER_31_273 VGND VGND VPWR VPWR sky130_fd_sc_hd__decap_3
XFILLER_31_284 VGND VGND VPWR VPWR sky130_fd_sc_hd__fill_1
X_6592_ _6592_/A VGND VGND VPWR VPWR _6592_/Y sky130_fd_sc_hd__inv_2
XFILLER_8_480 VGND VGND VPWR VPWR sky130_fd_sc_hd__decap_3
X_7213_ _7373_/CLK _7213_/D _6493_/Y VGND VGND VPWR VPWR _7213_/Q sky130_fd_sc_hd__dfrtp_2
X_4425_ _4425_/A _4649_/B _4425_/C VGND VGND VPWR VPWR _4426_/B sky130_fd_sc_hd__and3_2
X_7144_ _7374_/CLK _7144_/D _6424_/Y VGND VGND VPWR VPWR _7144_/Q sky130_fd_sc_hd__dfrtp_2
X_4356_ _7012_/Q _4601_/S _4272_/B _7353_/Q _4355_/X VGND VGND VPWR VPWR _4356_/X
+ sky130_fd_sc_hd__a221o_2
XFILLER_48_29 VGND VGND VPWR VPWR sky130_fd_sc_hd__fill_2
XFILLER_59_638 VGND VGND VPWR VPWR sky130_fd_sc_hd__decap_3
XFILLER_86_413 VGND VGND VPWR VPWR sky130_fd_sc_hd__decap_3
XFILLER_98_262 VGND VGND VPWR VPWR sky130_fd_sc_hd__decap_3
XFILLER_100_223 VGND VGND VPWR VPWR sky130_fd_sc_hd__decap_3
X_7075_ _7406_/CLK _7075_/D _6355_/Y VGND VGND VPWR VPWR _7075_/Q sky130_fd_sc_hd__dfrtp_2
X_4287_ _7286_/Q _5142_/S _3409_/X _7158_/Q VGND VGND VPWR VPWR _4288_/D sky130_fd_sc_hd__a22o_2
XFILLER_104_35 VGND VGND VPWR VPWR sky130_fd_sc_hd__decap_3
XFILLER_39_351 VGND VGND VPWR VPWR sky130_fd_sc_hd__fill_2
XFILLER_39_362 VGND VGND VPWR VPWR sky130_fd_sc_hd__decap_3
XFILLER_58_159 VGND VGND VPWR VPWR sky130_fd_sc_hd__decap_3
XFILLER_86_468 VGND VGND VPWR VPWR sky130_fd_sc_hd__decap_3
XFILLER_27_557 VGND VGND VPWR VPWR sky130_fd_sc_hd__decap_3
XFILLER_66_192 VGND VGND VPWR VPWR sky130_fd_sc_hd__decap_3
XFILLER_82_641 VGND VGND VPWR VPWR sky130_fd_sc_hd__decap_3
XFILLER_27_579 VGND VGND VPWR VPWR sky130_fd_sc_hd__decap_3
XFILLER_42_516 VGND VGND VPWR VPWR sky130_fd_sc_hd__decap_3
XFILLER_54_376 VGND VGND VPWR VPWR sky130_fd_sc_hd__decap_3
XFILLER_81_162 VGND VGND VPWR VPWR sky130_fd_sc_hd__decap_3
XTAP_TAPCELL_ROW_107_1469 VGND VPWR sky130_fd_sc_hd__tapvpwrvgnd_1
XFILLER_81_184 VGND VGND VPWR VPWR sky130_fd_sc_hd__decap_3
Xfanout22 _6260_/A VGND VGND VPWR VPWR _6344_/A sky130_fd_sc_hd__buf_1
X_6928_ _7071_/CLK _6928_/D VGND VGND VPWR VPWR _6928_/Q sky130_fd_sc_hd__dfxtp_2
Xfanout33 _6594_/A VGND VGND VPWR VPWR _6603_/A sky130_fd_sc_hd__buf_2
Xfanout44 fanout48/X VGND VGND VPWR VPWR _6608_/A sky130_fd_sc_hd__clkdlybuf4s25_1
Xfanout55 _6686_/A VGND VGND VPWR VPWR _6650_/A sky130_fd_sc_hd__buf_2
X_6859_ clkload3/A _6859_/D VGND VGND VPWR VPWR _6859_/Q sky130_fd_sc_hd__dfxtp_2
XFILLER_10_413 VGND VGND VPWR VPWR sky130_fd_sc_hd__decap_3
XFILLER_13_32 VGND VGND VPWR VPWR sky130_fd_sc_hd__decap_3
XFILLER_50_571 VGND VGND VPWR VPWR sky130_fd_sc_hd__fill_2
Xfanout66 fanout67/X VGND VGND VPWR VPWR _6616_/A sky130_fd_sc_hd__clkdlybuf4s25_1
XFILLER_6_417 VGND VGND VPWR VPWR sky130_fd_sc_hd__decap_3
XFILLER_13_98 VGND VGND VPWR VPWR sky130_fd_sc_hd__fill_2
XTAP_TAPCELL_ROW_20_463 VGND VPWR sky130_fd_sc_hd__tapvpwrvgnd_1
XFILLER_108_389 VGND VGND VPWR VPWR sky130_fd_sc_hd__decap_3
XFILLER_2_601 VGND VGND VPWR VPWR sky130_fd_sc_hd__decap_3
XFILLER_1_122 VGND VGND VPWR VPWR sky130_fd_sc_hd__decap_3
XFILLER_2_634 VGND VGND VPWR VPWR sky130_fd_sc_hd__decap_3
XFILLER_8_3 VGND VGND VPWR VPWR sky130_fd_sc_hd__decap_3
XFILLER_1_155 VGND VGND VPWR VPWR sky130_fd_sc_hd__fill_1
XFILLER_104_595 VGND VGND VPWR VPWR sky130_fd_sc_hd__decap_3
XFILLER_49_148 VGND VGND VPWR VPWR sky130_fd_sc_hd__decap_3
XFILLER_45_321 VGND VGND VPWR VPWR sky130_fd_sc_hd__fill_1
XFILLER_73_630 VGND VGND VPWR VPWR sky130_fd_sc_hd__decap_3
XFILLER_45_343 VGND VGND VPWR VPWR sky130_fd_sc_hd__fill_2
XFILLER_45_354 VGND VGND VPWR VPWR sky130_fd_sc_hd__fill_1
Xhold1180 _7163_/Q VGND VGND VPWR VPWR _5336_/A0 sky130_fd_sc_hd__dlygate4sd3_1
Xhold1191 _7310_/Q VGND VGND VPWR VPWR _4540_/A sky130_fd_sc_hd__dlygate4sd3_1
XTAP_TAPCELL_ROW_86_1222 VGND VPWR sky130_fd_sc_hd__tapvpwrvgnd_1
XFILLER_33_505 VGND VGND VPWR VPWR sky130_fd_sc_hd__decap_3
XFILLER_33_527 VGND VGND VPWR VPWR sky130_fd_sc_hd__decap_3
XTAP_TAPCELL_ROW_56_883 VGND VPWR sky130_fd_sc_hd__tapvpwrvgnd_1
XTAP_TAPCELL_ROW_28_552 VGND VPWR sky130_fd_sc_hd__tapvpwrvgnd_1
XFILLER_45_398 VGND VGND VPWR VPWR sky130_fd_sc_hd__decap_3
XFILLER_60_335 VGND VGND VPWR VPWR sky130_fd_sc_hd__decap_3
XFILLER_13_240 VGND VGND VPWR VPWR sky130_fd_sc_hd__fill_1
XFILLER_41_571 VGND VGND VPWR VPWR sky130_fd_sc_hd__decap_3
XFILLER_9_211 VGND VGND VPWR VPWR sky130_fd_sc_hd__decap_3
XFILLER_9_277 VGND VGND VPWR VPWR sky130_fd_sc_hd__decap_3
XFILLER_62_6 VGND VGND VPWR VPWR sky130_fd_sc_hd__decap_3
Xclkload14 _7349_/CLK VGND VGND VPWR VPWR clkload14/X sky130_fd_sc_hd__clkbuf_8
Xclkload25 _7397_/CLK VGND VGND VPWR VPWR clkload25/Y sky130_fd_sc_hd__inv_4
XTAP_TAPCELL_ROW_97_1351 VGND VPWR sky130_fd_sc_hd__tapvpwrvgnd_1
Xclkload36 _7372_/CLK VGND VGND VPWR VPWR clkload36/X sky130_fd_sc_hd__clkbuf_1
X_4210_ _4095_/A _4210_/B VGND VGND VPWR VPWR _4210_/X sky130_fd_sc_hd__and2b_2
XFILLER_68_413 VGND VGND VPWR VPWR sky130_fd_sc_hd__decap_3
X_5190_ _5190_/A _5225_/B VGND VGND VPWR VPWR _7233_/D sky130_fd_sc_hd__and2_2
XFILLER_95_210 VGND VGND VPWR VPWR sky130_fd_sc_hd__decap_3
X_4141_ _4141_/A _4141_/B VGND VGND VPWR VPWR _4142_/B sky130_fd_sc_hd__nor2_2
XFILLER_55_107 VGND VGND VPWR VPWR sky130_fd_sc_hd__decap_3
XFILLER_95_254 VGND VGND VPWR VPWR sky130_fd_sc_hd__decap_3
X_4072_ _7243_/Q _4430_/A2 _4459_/C1 _7179_/Q _4071_/X VGND VGND VPWR VPWR _4072_/X
+ sky130_fd_sc_hd__a221o_2
XPHY_EDGE_ROW_50_Left_159 VGND VGND VPWR VPWR sky130_fd_sc_hd__decap_3
XFILLER_48_170 VGND VGND VPWR VPWR sky130_fd_sc_hd__fill_1
XFILLER_83_427 VGND VGND VPWR VPWR sky130_fd_sc_hd__fill_1
XFILLER_95_287 VGND VGND VPWR VPWR sky130_fd_sc_hd__decap_3
XFILLER_64_641 VGND VGND VPWR VPWR sky130_fd_sc_hd__decap_3
XFILLER_24_527 VGND VGND VPWR VPWR sky130_fd_sc_hd__fill_1
XFILLER_36_365 VGND VGND VPWR VPWR sky130_fd_sc_hd__decap_3
XFILLER_51_302 VGND VGND VPWR VPWR sky130_fd_sc_hd__fill_1
XFILLER_24_549 VGND VGND VPWR VPWR sky130_fd_sc_hd__decap_3
XFILLER_51_324 VGND VGND VPWR VPWR sky130_fd_sc_hd__decap_3
XFILLER_51_346 VGND VGND VPWR VPWR sky130_fd_sc_hd__fill_2
X_4974_ _6993_/Q _4983_/B VGND VGND VPWR VPWR _4975_/B sky130_fd_sc_hd__xor2_2
X_6713_ _6943_/CLK _6713_/D VGND VGND VPWR VPWR _6713_/Q sky130_fd_sc_hd__dfxtp_2
X_3925_ _6687_/Q _5660_/B _3925_/B1 _6865_/Q VGND VGND VPWR VPWR _3925_/X sky130_fd_sc_hd__a22o_2
X_6644_ _6644_/A VGND VGND VPWR VPWR _6644_/Y sky130_fd_sc_hd__inv_2
Xclkload8 clkload8/A VGND VGND VPWR VPWR clkload8/X sky130_fd_sc_hd__clkbuf_1
X_3856_ _3845_/X _3855_/X _5151_/A VGND VGND VPWR VPWR _3856_/X sky130_fd_sc_hd__o21a_2
X_6575_ _6612_/A VGND VGND VPWR VPWR _6575_/Y sky130_fd_sc_hd__inv_2
X_3787_ _6739_/Q _3853_/A2 _3852_/B1 _6745_/Q _3786_/X VGND VGND VPWR VPWR _3787_/X
+ sky130_fd_sc_hd__a221o_2
XFILLER_105_337 VGND VGND VPWR VPWR sky130_fd_sc_hd__decap_3
XFILLER_105_359 VGND VGND VPWR VPWR sky130_fd_sc_hd__decap_3
XFILLER_59_28 VGND VGND VPWR VPWR sky130_fd_sc_hd__decap_3
Xoutput541 _7008_/Q VGND VGND VPWR VPWR pc_out[31] sky130_fd_sc_hd__clkdlybuf4s25_1
Xoutput530 _6998_/Q VGND VGND VPWR VPWR pc_out[21] sky130_fd_sc_hd__clkdlybuf4s25_1
X_4408_ _7024_/Q _4437_/A2 _4404_/X _4407_/X VGND VGND VPWR VPWR _4409_/B sky130_fd_sc_hd__a211o_2
X_5388_ _5388_/A0 _4913_/X _5388_/S VGND VGND VPWR VPWR _7139_/D sky130_fd_sc_hd__mux2_2
XFILLER_101_532 VGND VGND VPWR VPWR sky130_fd_sc_hd__decap_3
X_7127_ _7280_/CLK _7127_/D _6407_/Y VGND VGND VPWR VPWR _7127_/Q sky130_fd_sc_hd__dfrtp_2
X_4339_ _7287_/Q _4534_/S _4348_/A2 _7159_/Q VGND VGND VPWR VPWR _4339_/X sky130_fd_sc_hd__a22o_2
XTAP_TAPCELL_ROW_70_1045 VGND VPWR sky130_fd_sc_hd__tapvpwrvgnd_1
XTAP_TAPCELL_ROW_70_1034 VGND VPWR sky130_fd_sc_hd__tapvpwrvgnd_1
XFILLER_101_576 VGND VGND VPWR VPWR sky130_fd_sc_hd__fill_1
X_7058_ _7380_/CLK _7058_/D _6338_/Y VGND VGND VPWR VPWR _7058_/Q sky130_fd_sc_hd__dfstp_2
XFILLER_27_310 VGND VGND VPWR VPWR sky130_fd_sc_hd__decap_3
XFILLER_86_298 VGND VGND VPWR VPWR sky130_fd_sc_hd__decap_3
XFILLER_55_641 VGND VGND VPWR VPWR sky130_fd_sc_hd__decap_3
XFILLER_15_505 VGND VGND VPWR VPWR sky130_fd_sc_hd__decap_3
XFILLER_70_622 VGND VGND VPWR VPWR sky130_fd_sc_hd__decap_3
XTAP_TAPCELL_ROW_53_842 VGND VPWR sky130_fd_sc_hd__tapvpwrvgnd_1
XTAP_TAPCELL_ROW_25_522 VGND VPWR sky130_fd_sc_hd__tapvpwrvgnd_1
XFILLER_42_368 VGND VGND VPWR VPWR sky130_fd_sc_hd__decap_3
XFILLER_24_64 VGND VGND VPWR VPWR sky130_fd_sc_hd__decap_3
XTAP_TAPCELL_ROW_81_1163 VGND VPWR sky130_fd_sc_hd__tapvpwrvgnd_1
XFILLER_10_221 VGND VGND VPWR VPWR sky130_fd_sc_hd__decap_3
XFILLER_10_265 VGND VGND VPWR VPWR sky130_fd_sc_hd__decap_3
XFILLER_6_203 VGND VGND VPWR VPWR sky130_fd_sc_hd__decap_3
XFILLER_108_131 VGND VGND VPWR VPWR sky130_fd_sc_hd__decap_3
XFILLER_40_63 VGND VGND VPWR VPWR sky130_fd_sc_hd__decap_3
XFILLER_108_164 VGND VGND VPWR VPWR sky130_fd_sc_hd__decap_3
XFILLER_108_186 VGND VGND VPWR VPWR sky130_fd_sc_hd__fill_2
XFILLER_40_85 VGND VGND VPWR VPWR sky130_fd_sc_hd__decap_3
XFILLER_108_197 VGND VGND VPWR VPWR sky130_fd_sc_hd__fill_1
XFILLER_97_508 VGND VGND VPWR VPWR sky130_fd_sc_hd__decap_3
XFILLER_104_392 VGND VGND VPWR VPWR sky130_fd_sc_hd__fill_2
XTAP_TAPCELL_ROW_92_1292 VGND VPWR sky130_fd_sc_hd__tapvpwrvgnd_1
XFILLER_77_243 VGND VGND VPWR VPWR sky130_fd_sc_hd__fill_1
XTAP_TAPCELL_ROW_5_291 VGND VPWR sky130_fd_sc_hd__tapvpwrvgnd_1
XFILLER_1_57 VGND VGND VPWR VPWR sky130_fd_sc_hd__decap_3
XFILLER_46_641 VGND VGND VPWR VPWR sky130_fd_sc_hd__decap_3
XFILLER_18_354 VGND VGND VPWR VPWR sky130_fd_sc_hd__fill_1
XFILLER_18_365 VGND VGND VPWR VPWR sky130_fd_sc_hd__decap_3
XFILLER_45_151 VGND VGND VPWR VPWR sky130_fd_sc_hd__decap_3
XFILLER_73_471 VGND VGND VPWR VPWR sky130_fd_sc_hd__fill_1
XFILLER_60_110 VGND VGND VPWR VPWR sky130_fd_sc_hd__fill_2
XFILLER_61_644 VGND VGND VPWR VPWR sky130_fd_sc_hd__decap_3
XFILLER_21_508 VGND VGND VPWR VPWR sky130_fd_sc_hd__decap_3
XFILLER_33_357 VGND VGND VPWR VPWR sky130_fd_sc_hd__decap_3
XFILLER_60_165 VGND VGND VPWR VPWR sky130_fd_sc_hd__fill_1
XFILLER_14_571 VGND VGND VPWR VPWR sky130_fd_sc_hd__decap_3
X_3710_ hold974/X _4832_/A _3709_/X VGND VGND VPWR VPWR _7399_/D sky130_fd_sc_hd__o21a_2
X_4690_ _7005_/Q _5633_/B VGND VGND VPWR VPWR _4757_/A sky130_fd_sc_hd__and2_2
X_6360_ _6686_/A VGND VGND VPWR VPWR _6360_/Y sky130_fd_sc_hd__inv_2
X_3572_ _4295_/B _3607_/B VGND VGND VPWR VPWR _4292_/A sky130_fd_sc_hd__xnor2_2
X_6291_ _6592_/A VGND VGND VPWR VPWR _6291_/Y sky130_fd_sc_hd__inv_2
XFILLER_102_318 VGND VGND VPWR VPWR sky130_fd_sc_hd__decap_3
XFILLER_68_221 VGND VGND VPWR VPWR sky130_fd_sc_hd__decap_3
X_5173_ _5173_/A _5186_/B VGND VGND VPWR VPWR _7241_/D sky130_fd_sc_hd__and2_2
XFILLER_29_608 VGND VGND VPWR VPWR sky130_fd_sc_hd__decap_3
XFILLER_68_265 VGND VGND VPWR VPWR sky130_fd_sc_hd__fill_1
X_4124_ _4117_/Y _4124_/B VGND VGND VPWR VPWR _4126_/A sky130_fd_sc_hd__and2b_2
XFILLER_56_416 VGND VGND VPWR VPWR sky130_fd_sc_hd__decap_3
XFILLER_68_287 VGND VGND VPWR VPWR sky130_fd_sc_hd__decap_3
XFILLER_83_202 VGND VGND VPWR VPWR sky130_fd_sc_hd__decap_3
XFILLER_37_641 VGND VGND VPWR VPWR sky130_fd_sc_hd__decap_3
XFILLER_56_449 VGND VGND VPWR VPWR sky130_fd_sc_hd__fill_2
X_4055_ _4055_/A _4658_/A VGND VGND VPWR VPWR _4720_/A sky130_fd_sc_hd__nor2b_2
XFILLER_36_162 VGND VGND VPWR VPWR sky130_fd_sc_hd__decap_3
XFILLER_71_419 VGND VGND VPWR VPWR sky130_fd_sc_hd__decap_3
XFILLER_83_268 VGND VGND VPWR VPWR sky130_fd_sc_hd__decap_3
XFILLER_36_195 VGND VGND VPWR VPWR sky130_fd_sc_hd__fill_1
XFILLER_51_110 VGND VGND VPWR VPWR sky130_fd_sc_hd__fill_2
XFILLER_52_633 VGND VGND VPWR VPWR sky130_fd_sc_hd__decap_3
XTAP_TAPCELL_ROW_104_1428 VGND VPWR sky130_fd_sc_hd__tapvpwrvgnd_1
XFILLER_24_357 VGND VGND VPWR VPWR sky130_fd_sc_hd__decap_3
X_4957_ _4982_/B _5009_/A _6992_/Q VGND VGND VPWR VPWR _4983_/B sky130_fd_sc_hd__o21ai_2
XTAP_TAPCELL_ROW_50_812 VGND VPWR sky130_fd_sc_hd__tapvpwrvgnd_1
XFILLER_20_530 VGND VGND VPWR VPWR sky130_fd_sc_hd__fill_2
X_4888_ _4888_/A _4888_/B VGND VGND VPWR VPWR _4889_/B sky130_fd_sc_hd__or2_2
X_3908_ _3728_/B _3907_/X _5151_/A VGND VGND VPWR VPWR _3908_/X sky130_fd_sc_hd__o21a_2
X_6627_ _6630_/A VGND VGND VPWR VPWR _6627_/Y sky130_fd_sc_hd__inv_2
X_3839_ _3746_/X _3836_/X _3838_/X _3733_/X VGND VGND VPWR VPWR _3845_/A sky130_fd_sc_hd__a22o_2
X_6558_ _6558_/A VGND VGND VPWR VPWR _6558_/Y sky130_fd_sc_hd__inv_2
XTAP_TAPCELL_ROW_30_580 VGND VPWR sky130_fd_sc_hd__tapvpwrvgnd_1
XFILLER_106_613 VGND VGND VPWR VPWR sky130_fd_sc_hd__decap_3
XFILLER_3_228 VGND VGND VPWR VPWR sky130_fd_sc_hd__decap_3
X_6489_ _6686_/A VGND VGND VPWR VPWR _6489_/Y sky130_fd_sc_hd__inv_2
XFILLER_105_145 VGND VGND VPWR VPWR sky130_fd_sc_hd__decap_3
XFILLER_59_210 VGND VGND VPWR VPWR sky130_fd_sc_hd__fill_1
XFILLER_59_221 VGND VGND VPWR VPWR sky130_fd_sc_hd__decap_3
XFILLER_101_340 VGND VGND VPWR VPWR sky130_fd_sc_hd__fill_2
XFILLER_19_31 VGND VGND VPWR VPWR sky130_fd_sc_hd__fill_1
XFILLER_87_552 VGND VGND VPWR VPWR sky130_fd_sc_hd__decap_3
XTAP_TAPCELL_ROW_58_901 VGND VPWR sky130_fd_sc_hd__tapvpwrvgnd_1
XFILLER_101_351 VGND VGND VPWR VPWR sky130_fd_sc_hd__fill_1
XFILLER_101_373 VGND VGND VPWR VPWR sky130_fd_sc_hd__decap_3
XFILLER_19_53 VGND VGND VPWR VPWR sky130_fd_sc_hd__decap_3
XFILLER_59_276 VGND VGND VPWR VPWR sky130_fd_sc_hd__decap_3
XFILLER_87_574 VGND VGND VPWR VPWR sky130_fd_sc_hd__decap_3
XFILLER_19_75 VGND VGND VPWR VPWR sky130_fd_sc_hd__decap_3
XFILLER_19_86 VGND VGND VPWR VPWR sky130_fd_sc_hd__decap_3
Xclkbuf_leaf_39_clk clkbuf_3_2__f_clk/X VGND VGND VPWR VPWR _7376_/CLK sky130_fd_sc_hd__clkbuf_16
XFILLER_15_302 VGND VGND VPWR VPWR sky130_fd_sc_hd__fill_1
XFILLER_27_162 VGND VGND VPWR VPWR sky130_fd_sc_hd__decap_3
XTAP_TAPCELL_ROW_2_261 VGND VPWR sky130_fd_sc_hd__tapvpwrvgnd_1
XFILLER_15_313 VGND VGND VPWR VPWR sky130_fd_sc_hd__fill_1
XFILLER_43_644 VGND VGND VPWR VPWR sky130_fd_sc_hd__decap_3
XFILLER_70_430 VGND VGND VPWR VPWR sky130_fd_sc_hd__fill_2
XPHY_EDGE_ROW_106_Left_215 VGND VGND VPWR VPWR sky130_fd_sc_hd__decap_3
XFILLER_15_346 VGND VGND VPWR VPWR sky130_fd_sc_hd__decap_3
XFILLER_42_132 VGND VGND VPWR VPWR sky130_fd_sc_hd__decap_3
XFILLER_30_305 VGND VGND VPWR VPWR sky130_fd_sc_hd__decap_3
XFILLER_42_176 VGND VGND VPWR VPWR sky130_fd_sc_hd__decap_3
XFILLER_11_585 VGND VGND VPWR VPWR sky130_fd_sc_hd__decap_3
XFILLER_51_73 VGND VGND VPWR VPWR sky130_fd_sc_hd__decap_3
XFILLER_51_95 VGND VGND VPWR VPWR sky130_fd_sc_hd__decap_3
XFILLER_7_534 VGND VGND VPWR VPWR sky130_fd_sc_hd__decap_3
XFILLER_7_567 VGND VGND VPWR VPWR sky130_fd_sc_hd__decap_3
XTAP_TAPCELL_ROW_94_1321 VGND VPWR sky130_fd_sc_hd__tapvpwrvgnd_1
XTAP_TAPCELL_ROW_94_1310 VGND VPWR sky130_fd_sc_hd__tapvpwrvgnd_1
XFILLER_97_305 VGND VGND VPWR VPWR sky130_fd_sc_hd__decap_3
XFILLER_97_349 VGND VGND VPWR VPWR sky130_fd_sc_hd__decap_3
XFILLER_19_641 VGND VGND VPWR VPWR sky130_fd_sc_hd__decap_3
XFILLER_53_419 VGND VGND VPWR VPWR sky130_fd_sc_hd__decap_3
XFILLER_18_162 VGND VGND VPWR VPWR sky130_fd_sc_hd__decap_3
XFILLER_18_195 VGND VGND VPWR VPWR sky130_fd_sc_hd__fill_1
XFILLER_34_611 VGND VGND VPWR VPWR sky130_fd_sc_hd__decap_3
XFILLER_46_471 VGND VGND VPWR VPWR sky130_fd_sc_hd__fill_2
XFILLER_46_493 VGND VGND VPWR VPWR sky130_fd_sc_hd__decap_3
XFILLER_80_249 VGND VGND VPWR VPWR sky130_fd_sc_hd__decap_3
X_4811_ _4652_/B _4811_/B _4811_/C VGND VGND VPWR VPWR _4811_/X sky130_fd_sc_hd__and3b_2
XFILLER_33_198 VGND VGND VPWR VPWR sky130_fd_sc_hd__fill_2
X_4742_ _4069_/Y _4081_/X _4454_/X _4969_/B VGND VGND VPWR VPWR _4742_/Y sky130_fd_sc_hd__o211ai_2
X_4673_ _4982_/B _4673_/B VGND VGND VPWR VPWR _4680_/A sky130_fd_sc_hd__or2_2
X_6412_ _6609_/A VGND VGND VPWR VPWR _6412_/Y sky130_fd_sc_hd__inv_2
X_3624_ _5114_/A _3600_/A _4614_/C _5033_/B2 VGND VGND VPWR VPWR _3624_/X sky130_fd_sc_hd__a22o_2
X_7392_ _7392_/CLK _7392_/D _6672_/Y VGND VGND VPWR VPWR _7392_/Q sky130_fd_sc_hd__dfrtp_2
X_6343_ _6667_/A VGND VGND VPWR VPWR _6343_/Y sky130_fd_sc_hd__inv_2
X_3555_ _7285_/Q _4528_/B _3366_/X _7157_/Q VGND VGND VPWR VPWR _3556_/C sky130_fd_sc_hd__a22o_2
X_6274_ _6554_/A VGND VGND VPWR VPWR _6274_/Y sky130_fd_sc_hd__inv_2
X_3486_ _3502_/A _3502_/B _3485_/C VGND VGND VPWR VPWR _5144_/B sky130_fd_sc_hd__o21ai_2
XFILLER_103_638 VGND VGND VPWR VPWR sky130_fd_sc_hd__decap_3
X_5225_ _5225_/A _5225_/B VGND VGND VPWR VPWR _7216_/D sky130_fd_sc_hd__and2_2
XFILLER_102_159 VGND VGND VPWR VPWR sky130_fd_sc_hd__decap_3
X_5156_ _7010_/D _5155_/X _5156_/S VGND VGND VPWR VPWR _5156_/X sky130_fd_sc_hd__mux2_2
XFILLER_96_371 VGND VGND VPWR VPWR sky130_fd_sc_hd__decap_3
X_5087_ _5101_/B _5100_/B _5086_/A _4365_/X VGND VGND VPWR VPWR _5087_/Y sky130_fd_sc_hd__a211oi_2
X_4107_ _7301_/Q _4352_/A2 _4351_/A2 _7109_/Q _4106_/X VGND VGND VPWR VPWR _4107_/X
+ sky130_fd_sc_hd__a221o_2
XFILLER_25_600 VGND VGND VPWR VPWR sky130_fd_sc_hd__decap_3
XFILLER_44_408 VGND VGND VPWR VPWR sky130_fd_sc_hd__decap_3
XFILLER_44_419 VGND VGND VPWR VPWR sky130_fd_sc_hd__fill_1
X_4038_ _4039_/A _4458_/A VGND VGND VPWR VPWR _4608_/B sky130_fd_sc_hd__nor2_2
XFILLER_25_644 VGND VGND VPWR VPWR sky130_fd_sc_hd__decap_3
XFILLER_37_471 VGND VGND VPWR VPWR sky130_fd_sc_hd__decap_3
XFILLER_71_216 VGND VGND VPWR VPWR sky130_fd_sc_hd__decap_3
XFILLER_24_121 VGND VGND VPWR VPWR sky130_fd_sc_hd__decap_3
XFILLER_52_430 VGND VGND VPWR VPWR sky130_fd_sc_hd__decap_3
XFILLER_52_452 VGND VGND VPWR VPWR sky130_fd_sc_hd__decap_3
XFILLER_24_154 VGND VGND VPWR VPWR sky130_fd_sc_hd__decap_3
XFILLER_40_636 VGND VGND VPWR VPWR sky130_fd_sc_hd__decap_3
XFILLER_52_496 VGND VGND VPWR VPWR sky130_fd_sc_hd__decap_3
XFILLER_8_309 VGND VGND VPWR VPWR sky130_fd_sc_hd__decap_3
XFILLER_106_421 VGND VGND VPWR VPWR sky130_fd_sc_hd__decap_3
XFILLER_4_548 VGND VGND VPWR VPWR sky130_fd_sc_hd__decap_3
XFILLER_79_349 VGND VGND VPWR VPWR sky130_fd_sc_hd__decap_3
XTAP_TAPCELL_ROW_7_320 VGND VPWR sky130_fd_sc_hd__tapvpwrvgnd_1
XFILLER_87_382 VGND VGND VPWR VPWR sky130_fd_sc_hd__decap_3
XFILLER_101_181 VGND VGND VPWR VPWR sky130_fd_sc_hd__decap_3
XFILLER_101_192 VGND VGND VPWR VPWR sky130_fd_sc_hd__decap_3
XFILLER_47_246 VGND VGND VPWR VPWR sky130_fd_sc_hd__decap_3
XFILLER_87_393 VGND VGND VPWR VPWR sky130_fd_sc_hd__decap_3
XFILLER_16_622 VGND VGND VPWR VPWR sky130_fd_sc_hd__decap_3
XFILLER_62_227 VGND VGND VPWR VPWR sky130_fd_sc_hd__decap_3
XFILLER_90_547 VGND VGND VPWR VPWR sky130_fd_sc_hd__decap_3
XTAP_TAPCELL_ROW_33_609 VGND VPWR sky130_fd_sc_hd__tapvpwrvgnd_1
XFILLER_30_135 VGND VGND VPWR VPWR sky130_fd_sc_hd__decap_3
XFILLER_31_647 VGND VGND VPWR VPWR sky130_fd_sc_hd__fill_1
XFILLER_11_360 VGND VGND VPWR VPWR sky130_fd_sc_hd__decap_3
XFILLER_11_393 VGND VGND VPWR VPWR sky130_fd_sc_hd__decap_3
XFILLER_7_331 VGND VGND VPWR VPWR sky130_fd_sc_hd__decap_3
XTAP_TAPCELL_ROW_13_388 VGND VPWR sky130_fd_sc_hd__tapvpwrvgnd_1
XFILLER_7_353 VGND VGND VPWR VPWR sky130_fd_sc_hd__fill_2
XFILLER_7_386 VGND VGND VPWR VPWR sky130_fd_sc_hd__decap_3
XFILLER_7_89 VGND VGND VPWR VPWR sky130_fd_sc_hd__fill_1
X_3340_ _3340_/A _3340_/B _3340_/C VGND VGND VPWR VPWR _5640_/B sky130_fd_sc_hd__and3_2
XFILLER_3_570 VGND VGND VPWR VPWR sky130_fd_sc_hd__decap_3
XFILLER_97_113 VGND VGND VPWR VPWR sky130_fd_sc_hd__fill_2
X_5010_ _5010_/A _5662_/A _5010_/C _5010_/D VGND VGND VPWR VPWR _5010_/X sky130_fd_sc_hd__or4_2
XFILLER_97_146 VGND VGND VPWR VPWR sky130_fd_sc_hd__decap_3
Xhold1009 _7272_/Q VGND VGND VPWR VPWR _4823_/A0 sky130_fd_sc_hd__dlygate4sd3_1
XFILLER_66_555 VGND VGND VPWR VPWR sky130_fd_sc_hd__decap_3
XFILLER_38_268 VGND VGND VPWR VPWR sky130_fd_sc_hd__decap_3
XFILLER_53_205 VGND VGND VPWR VPWR sky130_fd_sc_hd__decap_3
XFILLER_81_514 VGND VGND VPWR VPWR sky130_fd_sc_hd__decap_3
XFILLER_93_352 VGND VGND VPWR VPWR sky130_fd_sc_hd__decap_3
XFILLER_93_363 VGND VGND VPWR VPWR sky130_fd_sc_hd__decap_3
XFILLER_19_493 VGND VGND VPWR VPWR sky130_fd_sc_hd__decap_3
X_6961_ clkload6/A _6961_/D VGND VGND VPWR VPWR _6961_/Q sky130_fd_sc_hd__dfxtp_2
XTAP_TAPCELL_ROW_49_797 VGND VPWR sky130_fd_sc_hd__tapvpwrvgnd_1
XFILLER_53_249 VGND VGND VPWR VPWR sky130_fd_sc_hd__decap_3
X_6892_ _6943_/CLK _6892_/D VGND VGND VPWR VPWR _6892_/Q sky130_fd_sc_hd__dfxtp_2
XFILLER_22_625 VGND VGND VPWR VPWR sky130_fd_sc_hd__decap_3
XFILLER_21_157 VGND VGND VPWR VPWR sky130_fd_sc_hd__decap_3
X_4725_ _4969_/B _4720_/X _4723_/X _4724_/X VGND VGND VPWR VPWR _5655_/A sky130_fd_sc_hd__a211o_2
X_7375_ _7383_/CLK _7375_/D _6655_/Y VGND VGND VPWR VPWR _7375_/Q sky130_fd_sc_hd__dfrtp_2
Xhold810 _6803_/Q VGND VGND VPWR VPWR _6803_/D sky130_fd_sc_hd__dlygate4sd3_1
Xhold821 _6787_/Q VGND VGND VPWR VPWR _6787_/D sky130_fd_sc_hd__dlygate4sd3_1
X_4587_ _4587_/A _4589_/B VGND VGND VPWR VPWR _7287_/D sky130_fd_sc_hd__and2_2
X_3607_ _4295_/B _3607_/B VGND VGND VPWR VPWR _3610_/A sky130_fd_sc_hd__nand2_2
Xhold832 _6720_/Q VGND VGND VPWR VPWR _6720_/D sky130_fd_sc_hd__dlygate4sd3_1
Xhold843 _7100_/Q VGND VGND VPWR VPWR _7100_/D sky130_fd_sc_hd__dlygate4sd3_1
Xhold854 _7065_/Q VGND VGND VPWR VPWR _7065_/D sky130_fd_sc_hd__dlygate4sd3_1
Xmax_cap551 _4447_/A VGND VGND VPWR VPWR _4795_/A sky130_fd_sc_hd__clkbuf_2
X_6326_ _6680_/A VGND VGND VPWR VPWR _6326_/Y sky130_fd_sc_hd__inv_2
X_3538_ _4327_/A _3456_/X _4537_/C _3421_/C VGND VGND VPWR VPWR _3544_/B sky130_fd_sc_hd__o2bb2a_2
XFILLER_103_402 VGND VGND VPWR VPWR sky130_fd_sc_hd__decap_3
XFILLER_107_46 VGND VGND VPWR VPWR sky130_fd_sc_hd__decap_3
XFILLER_107_57 VGND VGND VPWR VPWR sky130_fd_sc_hd__decap_3
XFILLER_1_529 VGND VGND VPWR VPWR sky130_fd_sc_hd__decap_3
Xhold865 _7089_/Q VGND VGND VPWR VPWR _7089_/D sky130_fd_sc_hd__dlygate4sd3_1
Xhold876 _7067_/Q VGND VGND VPWR VPWR _7067_/D sky130_fd_sc_hd__dlygate4sd3_1
Xhold887 _7085_/Q VGND VGND VPWR VPWR _7085_/D sky130_fd_sc_hd__dlygate4sd3_1
Xhold898 _7106_/Q VGND VGND VPWR VPWR _7106_/D sky130_fd_sc_hd__dlygate4sd3_1
Xmax_cap573 _6642_/A VGND VGND VPWR VPWR _6637_/A sky130_fd_sc_hd__buf_4
XFILLER_67_28 VGND VGND VPWR VPWR sky130_fd_sc_hd__decap_3
XFILLER_88_157 VGND VGND VPWR VPWR sky130_fd_sc_hd__decap_3
X_3469_ _3469_/A _3469_/B VGND VGND VPWR VPWR _4537_/C sky130_fd_sc_hd__nor2_2
XFILLER_29_202 VGND VGND VPWR VPWR sky130_fd_sc_hd__decap_3
XFILLER_57_500 VGND VGND VPWR VPWR sky130_fd_sc_hd__decap_3
XFILLER_69_382 VGND VGND VPWR VPWR sky130_fd_sc_hd__decap_3
XFILLER_69_393 VGND VGND VPWR VPWR sky130_fd_sc_hd__decap_3
XFILLER_84_330 VGND VGND VPWR VPWR sky130_fd_sc_hd__decap_3
X_5139_ _4677_/B _5138_/X _5092_/C VGND VGND VPWR VPWR _5139_/X sky130_fd_sc_hd__o21a_2
XFILLER_17_408 VGND VGND VPWR VPWR sky130_fd_sc_hd__fill_1
XFILLER_29_246 VGND VGND VPWR VPWR sky130_fd_sc_hd__decap_3
XFILLER_57_577 VGND VGND VPWR VPWR sky130_fd_sc_hd__decap_3
XFILLER_72_503 VGND VGND VPWR VPWR sky130_fd_sc_hd__decap_3
XFILLER_84_363 VGND VGND VPWR VPWR sky130_fd_sc_hd__fill_1
XTAP_TAPCELL_ROW_67_1006 VGND VPWR sky130_fd_sc_hd__tapvpwrvgnd_1
XFILLER_44_238 VGND VGND VPWR VPWR sky130_fd_sc_hd__decap_3
XFILLER_72_536 VGND VGND VPWR VPWR sky130_fd_sc_hd__fill_2
XFILLER_84_374 VGND VGND VPWR VPWR sky130_fd_sc_hd__decap_3
XFILLER_84_396 VGND VGND VPWR VPWR sky130_fd_sc_hd__decap_3
XFILLER_25_430 VGND VGND VPWR VPWR sky130_fd_sc_hd__decap_3
XFILLER_25_452 VGND VGND VPWR VPWR sky130_fd_sc_hd__decap_3
XFILLER_72_558 VGND VGND VPWR VPWR sky130_fd_sc_hd__decap_3
XFILLER_13_603 VGND VGND VPWR VPWR sky130_fd_sc_hd__decap_3
XFILLER_16_76 VGND VGND VPWR VPWR sky130_fd_sc_hd__fill_2
XFILLER_40_400 VGND VGND VPWR VPWR sky130_fd_sc_hd__decap_3
XFILLER_13_647 VGND VGND VPWR VPWR sky130_fd_sc_hd__fill_1
XFILLER_12_168 VGND VGND VPWR VPWR sky130_fd_sc_hd__decap_3
XFILLER_9_629 VGND VGND VPWR VPWR sky130_fd_sc_hd__decap_3
XFILLER_40_488 VGND VGND VPWR VPWR sky130_fd_sc_hd__decap_3
XTAP_TAPCELL_ROW_78_1135 VGND VPWR sky130_fd_sc_hd__tapvpwrvgnd_1
XTAP_TAPCELL_ROW_10_347 VGND VPWR sky130_fd_sc_hd__tapvpwrvgnd_1
XFILLER_4_312 VGND VGND VPWR VPWR sky130_fd_sc_hd__decap_3
XFILLER_79_113 VGND VGND VPWR VPWR sky130_fd_sc_hd__fill_1
XFILLER_79_124 VGND VGND VPWR VPWR sky130_fd_sc_hd__decap_3
XFILLER_79_146 VGND VGND VPWR VPWR sky130_fd_sc_hd__decap_3
XFILLER_95_639 VGND VGND VPWR VPWR sky130_fd_sc_hd__decap_3
XFILLER_95_617 VGND VGND VPWR VPWR sky130_fd_sc_hd__fill_1
XFILLER_0_584 VGND VGND VPWR VPWR sky130_fd_sc_hd__decap_3
XFILLER_0_595 VGND VGND VPWR VPWR sky130_fd_sc_hd__fill_2
XFILLER_102_490 VGND VGND VPWR VPWR sky130_fd_sc_hd__decap_3
XFILLER_48_522 VGND VGND VPWR VPWR sky130_fd_sc_hd__fill_1
XFILLER_87_190 VGND VGND VPWR VPWR sky130_fd_sc_hd__decap_3
XFILLER_94_127 VGND VGND VPWR VPWR sky130_fd_sc_hd__fill_1
XFILLER_63_503 VGND VGND VPWR VPWR sky130_fd_sc_hd__fill_1
XTAP_TAPCELL_ROW_89_1253 VGND VPWR sky130_fd_sc_hd__tapvpwrvgnd_1
XTAP_TAPCELL_ROW_46_767 VGND VPWR sky130_fd_sc_hd__tapvpwrvgnd_1
XTAP_TAPCELL_ROW_18_447 VGND VPWR sky130_fd_sc_hd__tapvpwrvgnd_1
XTAP_TAPCELL_ROW_18_436 VGND VPWR sky130_fd_sc_hd__tapvpwrvgnd_1
XFILLER_43_260 VGND VGND VPWR VPWR sky130_fd_sc_hd__fill_2
XFILLER_50_208 VGND VGND VPWR VPWR sky130_fd_sc_hd__decap_3
XFILLER_50_219 VGND VGND VPWR VPWR sky130_fd_sc_hd__decap_3
XFILLER_90_388 VGND VGND VPWR VPWR sky130_fd_sc_hd__decap_3
XFILLER_90_399 VGND VGND VPWR VPWR sky130_fd_sc_hd__decap_3
XFILLER_31_433 VGND VGND VPWR VPWR sky130_fd_sc_hd__fill_1
XFILLER_43_271 VGND VGND VPWR VPWR sky130_fd_sc_hd__fill_1
XFILLER_73_93 VGND VGND VPWR VPWR sky130_fd_sc_hd__fill_2
XFILLER_31_466 VGND VGND VPWR VPWR sky130_fd_sc_hd__decap_3
XFILLER_8_640 VGND VGND VPWR VPWR sky130_fd_sc_hd__decap_3
XFILLER_11_190 VGND VGND VPWR VPWR sky130_fd_sc_hd__decap_3
X_4510_ _4510_/A0 _7292_/Q _4520_/S VGND VGND VPWR VPWR _7324_/D sky130_fd_sc_hd__mux2_2
XFILLER_7_161 VGND VGND VPWR VPWR sky130_fd_sc_hd__decap_3
XFILLER_7_172 VGND VGND VPWR VPWR sky130_fd_sc_hd__decap_3
X_4441_ _4813_/B _4441_/B VGND VGND VPWR VPWR _4827_/A sky130_fd_sc_hd__nand2_2
X_7160_ _7280_/CLK _7160_/D _6440_/Y VGND VGND VPWR VPWR _7160_/Q sky130_fd_sc_hd__dfrtp_2
XPHY_EDGE_ROW_9_Right_9 VGND VGND VPWR VPWR sky130_fd_sc_hd__decap_3
X_4372_ _4372_/A _4627_/A VGND VGND VPWR VPWR _5018_/A sky130_fd_sc_hd__or2_2
X_7091_ _7350_/CLK _7091_/D _6371_/Y VGND VGND VPWR VPWR _7091_/Q sky130_fd_sc_hd__dfrtp_2
X_3323_ _5129_/A _3519_/B _5294_/A _3353_/B VGND VGND VPWR VPWR _3323_/X sky130_fd_sc_hd__a31o_2
XFILLER_98_455 VGND VGND VPWR VPWR sky130_fd_sc_hd__decap_3
XFILLER_98_433 VGND VGND VPWR VPWR sky130_fd_sc_hd__decap_3
XPHY_EDGE_ROW_107_Right_107 VGND VGND VPWR VPWR sky130_fd_sc_hd__decap_3
XFILLER_98_488 VGND VGND VPWR VPWR sky130_fd_sc_hd__decap_3
XFILLER_98_477 VGND VGND VPWR VPWR sky130_fd_sc_hd__fill_1
XFILLER_100_438 VGND VGND VPWR VPWR sky130_fd_sc_hd__decap_3
XFILLER_66_330 VGND VGND VPWR VPWR sky130_fd_sc_hd__decap_3
XFILLER_85_127 VGND VGND VPWR VPWR sky130_fd_sc_hd__decap_3
XFILLER_26_227 VGND VGND VPWR VPWR sky130_fd_sc_hd__decap_3
XFILLER_66_385 VGND VGND VPWR VPWR sky130_fd_sc_hd__decap_3
XFILLER_81_355 VGND VGND VPWR VPWR sky130_fd_sc_hd__fill_2
XFILLER_93_193 VGND VGND VPWR VPWR sky130_fd_sc_hd__decap_3
X_6944_ _6965_/CLK _6944_/D VGND VGND VPWR VPWR _6944_/Q sky130_fd_sc_hd__dfxtp_2
XFILLER_22_433 VGND VGND VPWR VPWR sky130_fd_sc_hd__decap_3
X_6875_ _6968_/CLK _6875_/D VGND VGND VPWR VPWR _6875_/Q sky130_fd_sc_hd__dfxtp_2
XFILLER_22_477 VGND VGND VPWR VPWR sky130_fd_sc_hd__decap_3
XFILLER_10_628 VGND VGND VPWR VPWR sky130_fd_sc_hd__decap_3
XFILLER_22_488 VGND VGND VPWR VPWR sky130_fd_sc_hd__decap_3
XFILLER_108_516 VGND VGND VPWR VPWR sky130_fd_sc_hd__fill_1
X_4708_ _7001_/Q _4825_/B VGND VGND VPWR VPWR _4826_/A sky130_fd_sc_hd__and2_2
X_5688_ _5688_/A0 _6694_/Q _5708_/S VGND VGND VPWR VPWR _6694_/D sky130_fd_sc_hd__mux2_2
X_4639_ _4639_/A _4948_/B VGND VGND VPWR VPWR _4918_/A sky130_fd_sc_hd__or2_2
XFILLER_78_38 VGND VGND VPWR VPWR sky130_fd_sc_hd__decap_3
X_7358_ _7361_/CLK _7358_/D _6638_/Y VGND VGND VPWR VPWR _7358_/Q sky130_fd_sc_hd__dfrtp_2
Xhold640 _6821_/Q VGND VGND VPWR VPWR _6821_/D sky130_fd_sc_hd__dlygate4sd3_1
Xhold651 _6722_/Q VGND VGND VPWR VPWR _6722_/D sky130_fd_sc_hd__dlygate4sd3_1
Xhold662 _6750_/Q VGND VGND VPWR VPWR _6750_/D sky130_fd_sc_hd__dlygate4sd3_1
XFILLER_89_444 VGND VGND VPWR VPWR sky130_fd_sc_hd__decap_3
X_7289_ _7356_/CLK _7289_/D _6569_/Y VGND VGND VPWR VPWR _7289_/Q sky130_fd_sc_hd__dfrtp_2
Xhold673 _6798_/Q VGND VGND VPWR VPWR _6798_/D sky130_fd_sc_hd__dlygate4sd3_1
Xhold684 _6815_/Q VGND VGND VPWR VPWR _6815_/D sky130_fd_sc_hd__dlygate4sd3_1
Xhold695 _6935_/Q VGND VGND VPWR VPWR _6935_/D sky130_fd_sc_hd__dlygate4sd3_1
X_6309_ _6536_/A VGND VGND VPWR VPWR _6309_/Y sky130_fd_sc_hd__inv_2
XTAP_TAPCELL_ROW_73_1076 VGND VPWR sky130_fd_sc_hd__tapvpwrvgnd_1
XFILLER_57_363 VGND VGND VPWR VPWR sky130_fd_sc_hd__fill_2
XFILLER_94_37 VGND VGND VPWR VPWR sky130_fd_sc_hd__decap_3
XFILLER_17_216 VGND VGND VPWR VPWR sky130_fd_sc_hd__decap_3
XFILLER_45_536 VGND VGND VPWR VPWR sky130_fd_sc_hd__decap_3
XFILLER_57_374 VGND VGND VPWR VPWR sky130_fd_sc_hd__decap_3
XFILLER_57_385 VGND VGND VPWR VPWR sky130_fd_sc_hd__decap_3
XFILLER_57_396 VGND VGND VPWR VPWR sky130_fd_sc_hd__decap_3
XFILLER_84_160 VGND VGND VPWR VPWR sky130_fd_sc_hd__decap_3
XFILLER_72_333 VGND VGND VPWR VPWR sky130_fd_sc_hd__decap_3
XFILLER_84_193 VGND VGND VPWR VPWR sky130_fd_sc_hd__decap_3
XFILLER_25_260 VGND VGND VPWR VPWR sky130_fd_sc_hd__fill_1
XFILLER_60_506 VGND VGND VPWR VPWR sky130_fd_sc_hd__decap_3
XFILLER_60_539 VGND VGND VPWR VPWR sky130_fd_sc_hd__fill_2
XFILLER_72_377 VGND VGND VPWR VPWR sky130_fd_sc_hd__fill_1
XTAP_TAPCELL_ROW_43_726 VGND VPWR sky130_fd_sc_hd__tapvpwrvgnd_1
XTAP_TAPCELL_ROW_15_406 VGND VPWR sky130_fd_sc_hd__tapvpwrvgnd_1
XFILLER_13_422 VGND VGND VPWR VPWR sky130_fd_sc_hd__decap_3
XFILLER_25_271 VGND VGND VPWR VPWR sky130_fd_sc_hd__decap_3
XFILLER_25_293 VGND VGND VPWR VPWR sky130_fd_sc_hd__decap_3
XFILLER_53_580 VGND VGND VPWR VPWR sky130_fd_sc_hd__decap_3
XFILLER_72_399 VGND VGND VPWR VPWR sky130_fd_sc_hd__fill_2
XFILLER_13_466 VGND VGND VPWR VPWR sky130_fd_sc_hd__decap_3
XFILLER_43_63 VGND VGND VPWR VPWR sky130_fd_sc_hd__decap_3
XFILLER_13_499 VGND VGND VPWR VPWR sky130_fd_sc_hd__decap_3
XTAP_TAPCELL_ROW_23_494 VGND VPWR sky130_fd_sc_hd__tapvpwrvgnd_1
XFILLER_5_632 VGND VGND VPWR VPWR sky130_fd_sc_hd__decap_3
XFILLER_57_9 VGND VGND VPWR VPWR sky130_fd_sc_hd__decap_3
XFILLER_4_186 VGND VGND VPWR VPWR sky130_fd_sc_hd__decap_3
XFILLER_4_197 VGND VGND VPWR VPWR sky130_fd_sc_hd__decap_3
XFILLER_67_105 VGND VGND VPWR VPWR sky130_fd_sc_hd__decap_3
XFILLER_68_639 VGND VGND VPWR VPWR sky130_fd_sc_hd__decap_3
XFILLER_95_414 VGND VGND VPWR VPWR sky130_fd_sc_hd__decap_3
XFILLER_67_149 VGND VGND VPWR VPWR sky130_fd_sc_hd__decap_3
XFILLER_95_447 VGND VGND VPWR VPWR sky130_fd_sc_hd__fill_1
XFILLER_36_503 VGND VGND VPWR VPWR sky130_fd_sc_hd__decap_3
XFILLER_48_341 VGND VGND VPWR VPWR sky130_fd_sc_hd__decap_3
XFILLER_36_536 VGND VGND VPWR VPWR sky130_fd_sc_hd__decap_3
XFILLER_91_631 VGND VGND VPWR VPWR sky130_fd_sc_hd__fill_2
XFILLER_75_182 VGND VGND VPWR VPWR sky130_fd_sc_hd__fill_1
XFILLER_90_130 VGND VGND VPWR VPWR sky130_fd_sc_hd__fill_2
XFILLER_91_642 VGND VGND VPWR VPWR sky130_fd_sc_hd__decap_3
Xplace322 _4599_/S VGND VGND VPWR VPWR _4260_/A2 sky130_fd_sc_hd__buf_2
Xplace311 _4573_/B VGND VGND VPWR VPWR _4563_/B sky130_fd_sc_hd__buf_2
Xplace300 _4361_/A VGND VGND VPWR VPWR _5086_/A sky130_fd_sc_hd__buf_2
XFILLER_23_208 VGND VGND VPWR VPWR sky130_fd_sc_hd__decap_3
XFILLER_90_163 VGND VGND VPWR VPWR sky130_fd_sc_hd__decap_3
Xplace355 _4352_/A2 VGND VGND VPWR VPWR _4865_/S sky130_fd_sc_hd__buf_2
Xplace344 _3618_/C VGND VGND VPWR VPWR _4764_/B sky130_fd_sc_hd__buf_2
Xplace333 _3586_/A VGND VGND VPWR VPWR _4376_/A sky130_fd_sc_hd__buf_2
X_4990_ _4620_/A _4989_/X _4374_/X VGND VGND VPWR VPWR _5004_/B sky130_fd_sc_hd__o21ai_2
XFILLER_51_539 VGND VGND VPWR VPWR sky130_fd_sc_hd__decap_3
XFILLER_63_399 VGND VGND VPWR VPWR sky130_fd_sc_hd__fill_1
Xplace377 _3423_/A VGND VGND VPWR VPWR _3857_/A2 sky130_fd_sc_hd__buf_2
Xplace388 _5633_/B VGND VGND VPWR VPWR _5622_/B sky130_fd_sc_hd__buf_2
Xplace366 _4338_/C1 VGND VGND VPWR VPWR _4347_/C1 sky130_fd_sc_hd__buf_2
X_3941_ _7369_/Q _4484_/A0 _3945_/S VGND VGND VPWR VPWR _7369_/D sky130_fd_sc_hd__mux2_2
XFILLER_90_3 VGND VGND VPWR VPWR sky130_fd_sc_hd__decap_3
Xplace399 _3488_/B VGND VGND VPWR VPWR _4244_/B sky130_fd_sc_hd__buf_2
X_6660_ _6662_/A VGND VGND VPWR VPWR _6660_/Y sky130_fd_sc_hd__inv_2
X_3872_ _6921_/Q _3888_/A2 _3893_/B1 _6695_/Q _3871_/X VGND VGND VPWR VPWR _3872_/X
+ sky130_fd_sc_hd__a221o_2
X_6591_ _6625_/A VGND VGND VPWR VPWR _6591_/Y sky130_fd_sc_hd__inv_2
X_5611_ _5611_/A _5634_/B VGND VGND VPWR VPWR _7022_/D sky130_fd_sc_hd__and2_2
XFILLER_8_470 VGND VGND VPWR VPWR sky130_fd_sc_hd__decap_3
XFILLER_105_508 VGND VGND VPWR VPWR sky130_fd_sc_hd__decap_3
X_7212_ _7372_/CLK _7212_/D _6492_/Y VGND VGND VPWR VPWR _7212_/Q sky130_fd_sc_hd__dfrtp_2
X_4424_ _4425_/A _4425_/C _4649_/B VGND VGND VPWR VPWR _4446_/A sky130_fd_sc_hd__a21oi_2
X_7143_ _7405_/CLK _7143_/D _6423_/Y VGND VGND VPWR VPWR _7143_/Q sky130_fd_sc_hd__dfrtp_2
X_4355_ _4355_/A _4355_/B VGND VGND VPWR VPWR _4355_/X sky130_fd_sc_hd__or2_2
XFILLER_98_230 VGND VGND VPWR VPWR sky130_fd_sc_hd__decap_3
XFILLER_59_606 VGND VGND VPWR VPWR sky130_fd_sc_hd__decap_3
XFILLER_59_617 VGND VGND VPWR VPWR sky130_fd_sc_hd__decap_3
X_7074_ _7397_/CLK _7074_/D _6354_/Y VGND VGND VPWR VPWR _7074_/Q sky130_fd_sc_hd__dfrtp_2
X_3306_ _5129_/A _3328_/A _6981_/D _4696_/B _3340_/B VGND VGND VPWR VPWR _3378_/A
+ sky130_fd_sc_hd__o221a_2
XFILLER_98_274 VGND VGND VPWR VPWR sky130_fd_sc_hd__decap_3
XFILLER_86_436 VGND VGND VPWR VPWR sky130_fd_sc_hd__decap_3
X_4286_ _4286_/A _4286_/B VGND VGND VPWR VPWR _4288_/C sky130_fd_sc_hd__or2_2
XFILLER_104_14 VGND VGND VPWR VPWR sky130_fd_sc_hd__decap_3
XFILLER_27_525 VGND VGND VPWR VPWR sky130_fd_sc_hd__decap_3
XFILLER_27_536 VGND VGND VPWR VPWR sky130_fd_sc_hd__decap_3
XFILLER_39_374 VGND VGND VPWR VPWR sky130_fd_sc_hd__decap_3
XFILLER_54_300 VGND VGND VPWR VPWR sky130_fd_sc_hd__decap_3
XFILLER_66_160 VGND VGND VPWR VPWR sky130_fd_sc_hd__decap_3
XFILLER_73_119 VGND VGND VPWR VPWR sky130_fd_sc_hd__decap_3
XFILLER_94_480 VGND VGND VPWR VPWR sky130_fd_sc_hd__decap_3
XFILLER_39_396 VGND VGND VPWR VPWR sky130_fd_sc_hd__decap_3
XFILLER_64_29 VGND VGND VPWR VPWR sky130_fd_sc_hd__decap_3
XFILLER_42_528 VGND VGND VPWR VPWR sky130_fd_sc_hd__decap_3
XFILLER_54_388 VGND VGND VPWR VPWR sky130_fd_sc_hd__decap_3
XFILLER_81_141 VGND VGND VPWR VPWR sky130_fd_sc_hd__decap_3
XFILLER_42_539 VGND VGND VPWR VPWR sky130_fd_sc_hd__decap_3
XFILLER_81_196 VGND VGND VPWR VPWR sky130_fd_sc_hd__decap_3
X_6927_ _7071_/CLK _6927_/D VGND VGND VPWR VPWR _6927_/Q sky130_fd_sc_hd__dfxtp_2
XFILLER_22_241 VGND VGND VPWR VPWR sky130_fd_sc_hd__decap_3
XFILLER_50_550 VGND VGND VPWR VPWR sky130_fd_sc_hd__decap_3
Xfanout23 reset VGND VGND VPWR VPWR _6260_/A sky130_fd_sc_hd__clkdlybuf4s25_1
Xfanout34 fanout48/X VGND VGND VPWR VPWR _6594_/A sky130_fd_sc_hd__clkdlybuf4s25_1
Xfanout45 _6644_/A VGND VGND VPWR VPWR _6609_/A sky130_fd_sc_hd__buf_2
Xfanout56 _6686_/A VGND VGND VPWR VPWR _6652_/A sky130_fd_sc_hd__clkdlybuf4s25_1
X_6858_ clkload8/A _6858_/D VGND VGND VPWR VPWR _6858_/Q sky130_fd_sc_hd__dfxtp_2
XFILLER_13_11 VGND VGND VPWR VPWR sky130_fd_sc_hd__decap_3
XFILLER_22_274 VGND VGND VPWR VPWR sky130_fd_sc_hd__decap_3
Xfanout67 _6685_/A VGND VGND VPWR VPWR fanout67/X sky130_fd_sc_hd__clkdlybuf4s25_1
XFILLER_13_55 VGND VGND VPWR VPWR sky130_fd_sc_hd__fill_1
XFILLER_22_296 VGND VGND VPWR VPWR sky130_fd_sc_hd__decap_3
X_6789_ clkload5/A _6789_/D VGND VGND VPWR VPWR _6789_/Q sky130_fd_sc_hd__dfxtp_2
XFILLER_6_429 VGND VGND VPWR VPWR sky130_fd_sc_hd__decap_3
XTAP_TAPCELL_ROW_20_464 VGND VPWR sky130_fd_sc_hd__tapvpwrvgnd_1
XFILLER_108_346 VGND VGND VPWR VPWR sky130_fd_sc_hd__decap_3
XFILLER_108_368 VGND VGND VPWR VPWR sky130_fd_sc_hd__decap_3
XFILLER_2_613 VGND VGND VPWR VPWR sky130_fd_sc_hd__decap_3
XFILLER_104_574 VGND VGND VPWR VPWR sky130_fd_sc_hd__decap_3
XFILLER_1_167 VGND VGND VPWR VPWR sky130_fd_sc_hd__fill_1
XFILLER_1_178 VGND VGND VPWR VPWR sky130_fd_sc_hd__decap_3
XFILLER_49_127 VGND VGND VPWR VPWR sky130_fd_sc_hd__decap_3
XFILLER_77_436 VGND VGND VPWR VPWR sky130_fd_sc_hd__decap_3
XFILLER_18_503 VGND VGND VPWR VPWR sky130_fd_sc_hd__decap_3
XFILLER_38_85 VGND VGND VPWR VPWR sky130_fd_sc_hd__decap_3
XFILLER_92_439 VGND VGND VPWR VPWR sky130_fd_sc_hd__decap_3
Xhold1170 _7140_/Q VGND VGND VPWR VPWR _5386_/A0 sky130_fd_sc_hd__dlygate4sd3_1
XFILLER_73_642 VGND VGND VPWR VPWR sky130_fd_sc_hd__decap_3
Xhold1181 _7171_/Q VGND VGND VPWR VPWR _5319_/A0 sky130_fd_sc_hd__dlygate4sd3_1
Xhold1192 _7302_/Q VGND VGND VPWR VPWR _4556_/A sky130_fd_sc_hd__dlygate4sd3_1
XTAP_TAPCELL_ROW_86_1223 VGND VPWR sky130_fd_sc_hd__tapvpwrvgnd_1
XFILLER_72_141 VGND VGND VPWR VPWR sky130_fd_sc_hd__decap_3
XTAP_TAPCELL_ROW_56_884 VGND VPWR sky130_fd_sc_hd__tapvpwrvgnd_1
XTAP_TAPCELL_ROW_56_873 VGND VPWR sky130_fd_sc_hd__tapvpwrvgnd_1
XTAP_TAPCELL_ROW_28_553 VGND VPWR sky130_fd_sc_hd__tapvpwrvgnd_1
XFILLER_33_539 VGND VGND VPWR VPWR sky130_fd_sc_hd__decap_3
XFILLER_13_252 VGND VGND VPWR VPWR sky130_fd_sc_hd__decap_3
XFILLER_13_274 VGND VGND VPWR VPWR sky130_fd_sc_hd__decap_3
XFILLER_41_594 VGND VGND VPWR VPWR sky130_fd_sc_hd__fill_1
XFILLER_9_234 VGND VGND VPWR VPWR sky130_fd_sc_hd__fill_1
XFILLER_9_223 VGND VGND VPWR VPWR sky130_fd_sc_hd__fill_1
XFILLER_9_256 VGND VGND VPWR VPWR sky130_fd_sc_hd__decap_3
Xclkload15 _7380_/CLK VGND VGND VPWR VPWR clkload15/X sky130_fd_sc_hd__clkbuf_8
Xclkload26 _6966_/CLK VGND VGND VPWR VPWR clkload26/Y sky130_fd_sc_hd__clkinv_2
Xclkload37 _7363_/CLK VGND VGND VPWR VPWR clkload37/Y sky130_fd_sc_hd__bufinv_16
XTAP_TAPCELL_ROW_97_1352 VGND VPWR sky130_fd_sc_hd__tapvpwrvgnd_1
XFILLER_5_484 VGND VGND VPWR VPWR sky130_fd_sc_hd__decap_3
X_4140_ _4117_/Y _4124_/B _4890_/B _4886_/A VGND VGND VPWR VPWR _4140_/X sky130_fd_sc_hd__a2bb2o_2
XFILLER_95_222 VGND VGND VPWR VPWR sky130_fd_sc_hd__fill_2
X_4071_ _7307_/Q _4488_/S _4437_/B1 _7371_/Q _4429_/C1 VGND VGND VPWR VPWR _4071_/X
+ sky130_fd_sc_hd__a221o_2
XFILLER_64_620 VGND VGND VPWR VPWR sky130_fd_sc_hd__decap_3
XFILLER_76_480 VGND VGND VPWR VPWR sky130_fd_sc_hd__fill_1
XFILLER_63_163 VGND VGND VPWR VPWR sky130_fd_sc_hd__decap_3
XFILLER_91_461 VGND VGND VPWR VPWR sky130_fd_sc_hd__decap_3
XFILLER_17_591 VGND VGND VPWR VPWR sky130_fd_sc_hd__decap_3
X_4973_ _4983_/A _4973_/B _3813_/Y VGND VGND VPWR VPWR _4973_/X sky130_fd_sc_hd__or3b_2
X_6712_ _6965_/CLK _6712_/D VGND VGND VPWR VPWR _6712_/Q sky130_fd_sc_hd__dfxtp_2
X_3924_ hold961/X _5138_/S _3923_/X VGND VGND VPWR VPWR _7376_/D sky130_fd_sc_hd__o21a_2
XFILLER_32_583 VGND VGND VPWR VPWR sky130_fd_sc_hd__decap_3
X_6643_ _6646_/A VGND VGND VPWR VPWR _6643_/Y sky130_fd_sc_hd__inv_2
Xclkload9 clkload9/A VGND VGND VPWR VPWR clkload9/Y sky130_fd_sc_hd__inv_6
X_3855_ _3728_/Y _3847_/X _3849_/X _3714_/X _3854_/X VGND VGND VPWR VPWR _3855_/X
+ sky130_fd_sc_hd__a221o_2
X_6574_ _6608_/A VGND VGND VPWR VPWR _6574_/Y sky130_fd_sc_hd__inv_2
X_3786_ _6751_/Q _3852_/A2 _3656_/Y _6733_/Q VGND VGND VPWR VPWR _3786_/X sky130_fd_sc_hd__a22o_2
XFILLER_105_305 VGND VGND VPWR VPWR sky130_fd_sc_hd__decap_3
Xoutput520 _6989_/Q VGND VGND VPWR VPWR pc_out[12] sky130_fd_sc_hd__clkdlybuf4s25_1
Xoutput542 _6980_/Q VGND VGND VPWR VPWR pc_out[3] sky130_fd_sc_hd__clkdlybuf4s25_1
Xoutput531 _6999_/Q VGND VGND VPWR VPWR pc_out[22] sky130_fd_sc_hd__clkdlybuf4s25_1
X_4407_ _7370_/Q _4394_/B _4436_/B1 _7178_/Q _4406_/X VGND VGND VPWR VPWR _4407_/X
+ sky130_fd_sc_hd__a221o_2
XFILLER_101_511 VGND VGND VPWR VPWR sky130_fd_sc_hd__decap_3
X_7126_ _7350_/CLK _7126_/D _6406_/Y VGND VGND VPWR VPWR _7126_/Q sky130_fd_sc_hd__dfrtp_2
X_4338_ _7319_/Q _3989_/S _4346_/B1 _7351_/Q _4338_/C1 VGND VGND VPWR VPWR _4338_/X
+ sky130_fd_sc_hd__a221o_2
XTAP_TAPCELL_ROW_70_1035 VGND VPWR sky130_fd_sc_hd__tapvpwrvgnd_1
XFILLER_101_544 VGND VGND VPWR VPWR sky130_fd_sc_hd__decap_3
XFILLER_59_458 VGND VGND VPWR VPWR sky130_fd_sc_hd__decap_3
XFILLER_86_233 VGND VGND VPWR VPWR sky130_fd_sc_hd__fill_2
X_7057_ _7380_/CLK _7057_/D _6337_/Y VGND VGND VPWR VPWR _7057_/Q sky130_fd_sc_hd__dfrtp_2
X_4269_ _7230_/Q _4353_/A2 _4244_/B _7043_/Q _4268_/X VGND VGND VPWR VPWR _4271_/C
+ sky130_fd_sc_hd__a221o_2
XFILLER_55_620 VGND VGND VPWR VPWR sky130_fd_sc_hd__decap_3
XFILLER_86_277 VGND VGND VPWR VPWR sky130_fd_sc_hd__decap_3
XFILLER_39_193 VGND VGND VPWR VPWR sky130_fd_sc_hd__decap_3
XFILLER_70_601 VGND VGND VPWR VPWR sky130_fd_sc_hd__fill_1
XFILLER_82_472 VGND VGND VPWR VPWR sky130_fd_sc_hd__decap_3
XFILLER_27_388 VGND VGND VPWR VPWR sky130_fd_sc_hd__decap_3
XFILLER_42_336 VGND VGND VPWR VPWR sky130_fd_sc_hd__fill_1
XFILLER_70_634 VGND VGND VPWR VPWR sky130_fd_sc_hd__decap_3
XFILLER_70_645 VGND VGND VPWR VPWR sky130_fd_sc_hd__decap_3
XFILLER_82_483 VGND VGND VPWR VPWR sky130_fd_sc_hd__decap_3
XTAP_TAPCELL_ROW_25_523 VGND VPWR sky130_fd_sc_hd__tapvpwrvgnd_1
XTAP_TAPCELL_ROW_53_843 VGND VPWR sky130_fd_sc_hd__tapvpwrvgnd_1
XFILLER_10_200 VGND VGND VPWR VPWR sky130_fd_sc_hd__decap_3
XFILLER_23_561 VGND VGND VPWR VPWR sky130_fd_sc_hd__decap_3
XTAP_TAPCELL_ROW_81_1164 VGND VPWR sky130_fd_sc_hd__tapvpwrvgnd_1
XFILLER_10_233 VGND VGND VPWR VPWR sky130_fd_sc_hd__decap_3
XFILLER_10_244 VGND VGND VPWR VPWR sky130_fd_sc_hd__decap_3
XFILLER_10_277 VGND VGND VPWR VPWR sky130_fd_sc_hd__decap_3
XFILLER_6_215 VGND VGND VPWR VPWR sky130_fd_sc_hd__decap_3
XFILLER_6_226 VGND VGND VPWR VPWR sky130_fd_sc_hd__decap_3
XFILLER_10_299 VGND VGND VPWR VPWR sky130_fd_sc_hd__decap_3
XFILLER_2_410 VGND VGND VPWR VPWR sky130_fd_sc_hd__decap_3
XFILLER_2_432 VGND VGND VPWR VPWR sky130_fd_sc_hd__fill_1
XFILLER_104_371 VGND VGND VPWR VPWR sky130_fd_sc_hd__decap_3
XFILLER_49_51 VGND VGND VPWR VPWR sky130_fd_sc_hd__fill_1
XTAP_TAPCELL_ROW_92_1293 VGND VPWR sky130_fd_sc_hd__tapvpwrvgnd_1
XFILLER_38_609 VGND VGND VPWR VPWR sky130_fd_sc_hd__decap_3
XFILLER_77_255 VGND VGND VPWR VPWR sky130_fd_sc_hd__decap_3
XFILLER_18_300 VGND VGND VPWR VPWR sky130_fd_sc_hd__decap_3
XFILLER_92_203 VGND VGND VPWR VPWR sky130_fd_sc_hd__decap_3
XFILLER_46_620 VGND VGND VPWR VPWR sky130_fd_sc_hd__decap_3
XFILLER_58_480 VGND VGND VPWR VPWR sky130_fd_sc_hd__decap_3
XFILLER_92_225 VGND VGND VPWR VPWR sky130_fd_sc_hd__decap_3
XTAP_TAPCELL_ROW_5_292 VGND VPWR sky130_fd_sc_hd__tapvpwrvgnd_1
XFILLER_45_163 VGND VGND VPWR VPWR sky130_fd_sc_hd__decap_3
XFILLER_61_612 VGND VGND VPWR VPWR sky130_fd_sc_hd__decap_3
XFILLER_73_461 VGND VGND VPWR VPWR sky130_fd_sc_hd__fill_1
XFILLER_45_185 VGND VGND VPWR VPWR sky130_fd_sc_hd__decap_3
XFILLER_61_623 VGND VGND VPWR VPWR sky130_fd_sc_hd__decap_3
XFILLER_60_155 VGND VGND VPWR VPWR sky130_fd_sc_hd__fill_2
XFILLER_14_583 VGND VGND VPWR VPWR sky130_fd_sc_hd__decap_3
XFILLER_41_391 VGND VGND VPWR VPWR sky130_fd_sc_hd__fill_1
X_3640_ _3635_/X _3637_/X _3639_/X VGND VGND VPWR VPWR _3640_/X sky130_fd_sc_hd__o21ba_2
X_3571_ _5648_/A _3424_/S _5648_/B _3569_/X _3570_/X VGND VGND VPWR VPWR _3607_/B
+ sky130_fd_sc_hd__o32a_2
X_6290_ _6364_/A VGND VGND VPWR VPWR _6290_/Y sky130_fd_sc_hd__inv_2
X_5310_ _5310_/A0 _4836_/X _5310_/S VGND VGND VPWR VPWR _7175_/D sky130_fd_sc_hd__mux2_2
XFILLER_5_281 VGND VGND VPWR VPWR sky130_fd_sc_hd__decap_3
XFILLER_5_292 VGND VGND VPWR VPWR sky130_fd_sc_hd__decap_3
XFILLER_88_509 VGND VGND VPWR VPWR sky130_fd_sc_hd__decap_3
X_5241_ _5241_/A0 _4806_/X _5276_/S VGND VGND VPWR VPWR _7209_/D sky130_fd_sc_hd__mux2_2
XFILLER_68_200 VGND VGND VPWR VPWR sky130_fd_sc_hd__decap_3
XFILLER_68_233 VGND VGND VPWR VPWR sky130_fd_sc_hd__decap_3
XFILLER_68_244 VGND VGND VPWR VPWR sky130_fd_sc_hd__decap_3
X_4123_ _4119_/X _4122_/X _4327_/A VGND VGND VPWR VPWR _4124_/B sky130_fd_sc_hd__o21a_2
XFILLER_96_542 VGND VGND VPWR VPWR sky130_fd_sc_hd__decap_3
XFILLER_83_214 VGND VGND VPWR VPWR sky130_fd_sc_hd__decap_3
X_4054_ _4054_/A _4456_/A VGND VGND VPWR VPWR _4658_/A sky130_fd_sc_hd__nand2_2
XFILLER_96_586 VGND VGND VPWR VPWR sky130_fd_sc_hd__fill_2
XFILLER_37_620 VGND VGND VPWR VPWR sky130_fd_sc_hd__decap_3
XFILLER_83_225 VGND VGND VPWR VPWR sky130_fd_sc_hd__decap_3
XFILLER_36_130 VGND VGND VPWR VPWR sky130_fd_sc_hd__decap_3
XFILLER_36_141 VGND VGND VPWR VPWR sky130_fd_sc_hd__decap_3
XFILLER_101_15 VGND VGND VPWR VPWR sky130_fd_sc_hd__decap_3
XFILLER_36_174 VGND VGND VPWR VPWR sky130_fd_sc_hd__decap_3
XFILLER_52_612 VGND VGND VPWR VPWR sky130_fd_sc_hd__decap_3
XFILLER_52_645 VGND VGND VPWR VPWR sky130_fd_sc_hd__decap_3
XFILLER_64_472 VGND VGND VPWR VPWR sky130_fd_sc_hd__decap_3
XTAP_TAPCELL_ROW_104_1429 VGND VPWR sky130_fd_sc_hd__tapvpwrvgnd_1
XFILLER_51_122 VGND VGND VPWR VPWR sky130_fd_sc_hd__decap_3
XFILLER_51_133 VGND VGND VPWR VPWR sky130_fd_sc_hd__decap_3
XFILLER_51_155 VGND VGND VPWR VPWR sky130_fd_sc_hd__decap_3
XFILLER_91_291 VGND VGND VPWR VPWR sky130_fd_sc_hd__decap_3
X_4956_ _4948_/Y _4951_/Y _4954_/X _4955_/X VGND VGND VPWR VPWR _5662_/C sky130_fd_sc_hd__a211o_2
XTAP_TAPCELL_ROW_50_813 VGND VPWR sky130_fd_sc_hd__tapvpwrvgnd_1
X_4887_ _4886_/A _4890_/B _4814_/A VGND VGND VPWR VPWR _4887_/Y sky130_fd_sc_hd__a21oi_2
X_3907_ _6781_/Q _3651_/Y _3925_/B1 _6869_/Q _3906_/X VGND VGND VPWR VPWR _3907_/X
+ sky130_fd_sc_hd__a221o_2
X_6626_ _6632_/A VGND VGND VPWR VPWR _6626_/Y sky130_fd_sc_hd__inv_2
X_3838_ _6773_/Q _3886_/A2 _3886_/B1 _6761_/Q _3837_/X VGND VGND VPWR VPWR _3838_/X
+ sky130_fd_sc_hd__a221o_2
XFILLER_20_586 VGND VGND VPWR VPWR sky130_fd_sc_hd__fill_2
X_6557_ _6557_/A VGND VGND VPWR VPWR _6557_/Y sky130_fd_sc_hd__inv_2
XTAP_TAPCELL_ROW_30_581 VGND VPWR sky130_fd_sc_hd__tapvpwrvgnd_1
XFILLER_106_625 VGND VGND VPWR VPWR sky130_fd_sc_hd__decap_3
XFILLER_3_207 VGND VGND VPWR VPWR sky130_fd_sc_hd__decap_3
X_3769_ _3746_/C _3767_/X _3768_/X _3867_/B1 VGND VGND VPWR VPWR _4944_/B sky130_fd_sc_hd__o31a_2
X_6488_ _6648_/A VGND VGND VPWR VPWR _6488_/Y sky130_fd_sc_hd__inv_2
XFILLER_105_179 VGND VGND VPWR VPWR sky130_fd_sc_hd__fill_1
XFILLER_87_564 VGND VGND VPWR VPWR sky130_fd_sc_hd__fill_2
X_7109_ _7366_/CLK _7109_/D _6389_/Y VGND VGND VPWR VPWR _7109_/Q sky130_fd_sc_hd__dfrtp_2
XFILLER_59_266 VGND VGND VPWR VPWR sky130_fd_sc_hd__decap_3
XFILLER_74_203 VGND VGND VPWR VPWR sky130_fd_sc_hd__fill_1
XTAP_TAPCELL_ROW_58_902 VGND VPWR sky130_fd_sc_hd__tapvpwrvgnd_1
XFILLER_101_396 VGND VGND VPWR VPWR sky130_fd_sc_hd__decap_3
XFILLER_28_631 VGND VGND VPWR VPWR sky130_fd_sc_hd__decap_3
XTAP_TAPCELL_ROW_2_262 VGND VPWR sky130_fd_sc_hd__tapvpwrvgnd_1
XFILLER_43_623 VGND VGND VPWR VPWR sky130_fd_sc_hd__decap_3
XFILLER_82_280 VGND VGND VPWR VPWR sky130_fd_sc_hd__fill_1
XTAP_TAPCELL_ROW_66_990 VGND VPWR sky130_fd_sc_hd__tapvpwrvgnd_1
XTAP_TAPCELL_ROW_38_670 VGND VPWR sky130_fd_sc_hd__tapvpwrvgnd_1
XFILLER_15_369 VGND VGND VPWR VPWR sky130_fd_sc_hd__decap_3
XFILLER_42_144 VGND VGND VPWR VPWR sky130_fd_sc_hd__decap_3
XFILLER_42_166 VGND VGND VPWR VPWR sky130_fd_sc_hd__fill_2
XFILLER_42_188 VGND VGND VPWR VPWR sky130_fd_sc_hd__decap_3
XFILLER_70_486 VGND VGND VPWR VPWR sky130_fd_sc_hd__decap_3
XFILLER_11_564 VGND VGND VPWR VPWR sky130_fd_sc_hd__decap_3
XFILLER_11_597 VGND VGND VPWR VPWR sky130_fd_sc_hd__decap_3
XFILLER_7_579 VGND VGND VPWR VPWR sky130_fd_sc_hd__decap_3
XTAP_TAPCELL_ROW_94_1311 VGND VPWR sky130_fd_sc_hd__tapvpwrvgnd_1
XFILLER_2_251 VGND VGND VPWR VPWR sky130_fd_sc_hd__fill_1
XFILLER_2_262 VGND VGND VPWR VPWR sky130_fd_sc_hd__decap_3
XFILLER_2_273 VGND VGND VPWR VPWR sky130_fd_sc_hd__decap_3
XFILLER_97_317 VGND VGND VPWR VPWR sky130_fd_sc_hd__decap_3
XFILLER_78_531 VGND VGND VPWR VPWR sky130_fd_sc_hd__fill_1
XFILLER_38_417 VGND VGND VPWR VPWR sky130_fd_sc_hd__decap_3
XFILLER_65_214 VGND VGND VPWR VPWR sky130_fd_sc_hd__decap_3
XFILLER_19_620 VGND VGND VPWR VPWR sky130_fd_sc_hd__decap_3
XFILLER_65_225 VGND VGND VPWR VPWR sky130_fd_sc_hd__decap_3
XFILLER_76_82 VGND VGND VPWR VPWR sky130_fd_sc_hd__fill_2
XFILLER_93_534 VGND VGND VPWR VPWR sky130_fd_sc_hd__decap_3
XFILLER_18_141 VGND VGND VPWR VPWR sky130_fd_sc_hd__decap_3
XFILLER_80_206 VGND VGND VPWR VPWR sky130_fd_sc_hd__decap_3
XFILLER_93_589 VGND VGND VPWR VPWR sky130_fd_sc_hd__fill_2
XFILLER_18_174 VGND VGND VPWR VPWR sky130_fd_sc_hd__decap_3
XFILLER_34_623 VGND VGND VPWR VPWR sky130_fd_sc_hd__decap_3
XFILLER_34_645 VGND VGND VPWR VPWR sky130_fd_sc_hd__decap_3
X_4810_ _4813_/A _4810_/B _4829_/B VGND VGND VPWR VPWR _4810_/X sky130_fd_sc_hd__or3_2
XFILLER_33_155 VGND VGND VPWR VPWR sky130_fd_sc_hd__decap_3
XFILLER_33_166 VGND VGND VPWR VPWR sky130_fd_sc_hd__fill_2
XFILLER_92_92 VGND VGND VPWR VPWR sky130_fd_sc_hd__decap_3
X_4741_ _4761_/B _4761_/C _4762_/B VGND VGND VPWR VPWR _4741_/X sky130_fd_sc_hd__a21o_2
X_4672_ _6991_/Q _5628_/B VGND VGND VPWR VPWR _4673_/B sky130_fd_sc_hd__nor2_2
X_6411_ _6602_/A VGND VGND VPWR VPWR _6411_/Y sky130_fd_sc_hd__inv_2
X_7391_ _7398_/CLK _7391_/D _6671_/Y VGND VGND VPWR VPWR _7391_/Q sky130_fd_sc_hd__dfrtp_2
X_6342_ _6463_/A VGND VGND VPWR VPWR _6342_/Y sky130_fd_sc_hd__inv_2
X_3554_ _7317_/Q _3994_/S _4285_/B1 _7349_/Q VGND VGND VPWR VPWR _3556_/B sky130_fd_sc_hd__a22o_2
XFILLER_103_617 VGND VGND VPWR VPWR sky130_fd_sc_hd__decap_3
XFILLER_88_306 VGND VGND VPWR VPWR sky130_fd_sc_hd__fill_2
X_6273_ _6554_/A VGND VGND VPWR VPWR _6273_/Y sky130_fd_sc_hd__inv_2
X_3485_ _3502_/A _3502_/B _3485_/C VGND VGND VPWR VPWR _5144_/A sky130_fd_sc_hd__or3_4
XFILLER_88_339 VGND VGND VPWR VPWR sky130_fd_sc_hd__decap_3
XFILLER_69_542 VGND VGND VPWR VPWR sky130_fd_sc_hd__decap_3
XFILLER_84_501 VGND VGND VPWR VPWR sky130_fd_sc_hd__decap_3
X_5155_ _4467_/B _3923_/X _5151_/X _5154_/Y VGND VGND VPWR VPWR _5155_/X sky130_fd_sc_hd__a31o_2
XFILLER_29_439 VGND VGND VPWR VPWR sky130_fd_sc_hd__decap_3
XFILLER_56_247 VGND VGND VPWR VPWR sky130_fd_sc_hd__decap_3
XFILLER_84_545 VGND VGND VPWR VPWR sky130_fd_sc_hd__decap_3
X_5086_ _5086_/A _5101_/B _5100_/B VGND VGND VPWR VPWR _5086_/X sky130_fd_sc_hd__and3_2
X_4106_ _7141_/Q _4267_/A2 _4103_/X _4105_/X VGND VGND VPWR VPWR _4106_/X sky130_fd_sc_hd__a211o_2
XFILLER_71_206 VGND VGND VPWR VPWR sky130_fd_sc_hd__decap_3
X_4037_ _4394_/A _4394_/B _4036_/X VGND VGND VPWR VPWR _4458_/A sky130_fd_sc_hd__or3b_2
XFILLER_25_612 VGND VGND VPWR VPWR sky130_fd_sc_hd__decap_3
XFILLER_25_623 VGND VGND VPWR VPWR sky130_fd_sc_hd__decap_3
XFILLER_71_228 VGND VGND VPWR VPWR sky130_fd_sc_hd__decap_3
XFILLER_24_144 VGND VGND VPWR VPWR sky130_fd_sc_hd__fill_1
XFILLER_72_29 VGND VGND VPWR VPWR sky130_fd_sc_hd__fill_1
XTAP_TAPCELL_ROW_35_640 VGND VPWR sky130_fd_sc_hd__tapvpwrvgnd_1
XFILLER_12_306 VGND VGND VPWR VPWR sky130_fd_sc_hd__fill_2
XFILLER_24_177 VGND VGND VPWR VPWR sky130_fd_sc_hd__fill_2
XFILLER_40_615 VGND VGND VPWR VPWR sky130_fd_sc_hd__decap_3
XTAP_TAPCELL_ROW_63_960 VGND VPWR sky130_fd_sc_hd__tapvpwrvgnd_1
XFILLER_12_328 VGND VGND VPWR VPWR sky130_fd_sc_hd__fill_2
XFILLER_24_188 VGND VGND VPWR VPWR sky130_fd_sc_hd__fill_1
X_4939_ _4764_/B _4379_/B _4938_/Y _4937_/A _4852_/A VGND VGND VPWR VPWR _4939_/X
+ sky130_fd_sc_hd__o32a_2
XFILLER_20_361 VGND VGND VPWR VPWR sky130_fd_sc_hd__decap_3
XFILLER_21_11 VGND VGND VPWR VPWR sky130_fd_sc_hd__fill_2
X_6609_ _6609_/A VGND VGND VPWR VPWR _6609_/Y sky130_fd_sc_hd__inv_2
XFILLER_20_394 VGND VGND VPWR VPWR sky130_fd_sc_hd__decap_3
XFILLER_21_55 VGND VGND VPWR VPWR sky130_fd_sc_hd__fill_1
XFILLER_106_433 VGND VGND VPWR VPWR sky130_fd_sc_hd__decap_3
XFILLER_106_488 VGND VGND VPWR VPWR sky130_fd_sc_hd__fill_1
XFILLER_79_328 VGND VGND VPWR VPWR sky130_fd_sc_hd__decap_3
XTAP_TAPCELL_ROW_7_310 VGND VPWR sky130_fd_sc_hd__tapvpwrvgnd_1
XFILLER_75_501 VGND VGND VPWR VPWR sky130_fd_sc_hd__decap_3
XFILLER_47_214 VGND VGND VPWR VPWR sky130_fd_sc_hd__decap_3
XFILLER_35_409 VGND VGND VPWR VPWR sky130_fd_sc_hd__decap_3
XFILLER_62_206 VGND VGND VPWR VPWR sky130_fd_sc_hd__decap_3
XFILLER_75_578 VGND VGND VPWR VPWR sky130_fd_sc_hd__decap_3
XFILLER_16_601 VGND VGND VPWR VPWR sky130_fd_sc_hd__decap_3
XFILLER_16_634 VGND VGND VPWR VPWR sky130_fd_sc_hd__decap_3
XFILLER_28_461 VGND VGND VPWR VPWR sky130_fd_sc_hd__decap_3
XFILLER_28_494 VGND VGND VPWR VPWR sky130_fd_sc_hd__fill_1
XFILLER_46_74 VGND VGND VPWR VPWR sky130_fd_sc_hd__fill_2
XFILLER_62_239 VGND VGND VPWR VPWR sky130_fd_sc_hd__decap_3
XFILLER_15_144 VGND VGND VPWR VPWR sky130_fd_sc_hd__decap_3
XFILLER_16_645 VGND VGND VPWR VPWR sky130_fd_sc_hd__decap_3
XFILLER_43_442 VGND VGND VPWR VPWR sky130_fd_sc_hd__decap_3
XFILLER_55_291 VGND VGND VPWR VPWR sky130_fd_sc_hd__decap_3
XFILLER_102_91 VGND VGND VPWR VPWR sky130_fd_sc_hd__decap_3
XFILLER_31_604 VGND VGND VPWR VPWR sky130_fd_sc_hd__decap_3
XFILLER_31_626 VGND VGND VPWR VPWR sky130_fd_sc_hd__decap_3
XFILLER_70_250 VGND VGND VPWR VPWR sky130_fd_sc_hd__fill_2
XFILLER_30_114 VGND VGND VPWR VPWR sky130_fd_sc_hd__decap_3
XFILLER_62_73 VGND VGND VPWR VPWR sky130_fd_sc_hd__decap_3
XTAP_TAPCELL_ROW_13_389 VGND VPWR sky130_fd_sc_hd__tapvpwrvgnd_1
XFILLER_7_365 VGND VGND VPWR VPWR sky130_fd_sc_hd__decap_3
XFILLER_7_68 VGND VGND VPWR VPWR sky130_fd_sc_hd__decap_3
XFILLER_3_582 VGND VGND VPWR VPWR sky130_fd_sc_hd__decap_3
XFILLER_98_637 VGND VGND VPWR VPWR sky130_fd_sc_hd__decap_3
XFILLER_97_125 VGND VGND VPWR VPWR sky130_fd_sc_hd__decap_3
XFILLER_97_158 VGND VGND VPWR VPWR sky130_fd_sc_hd__decap_3
XFILLER_38_236 VGND VGND VPWR VPWR sky130_fd_sc_hd__fill_2
XFILLER_78_383 VGND VGND VPWR VPWR sky130_fd_sc_hd__decap_3
XFILLER_26_409 VGND VGND VPWR VPWR sky130_fd_sc_hd__decap_3
XFILLER_66_589 VGND VGND VPWR VPWR sky130_fd_sc_hd__decap_3
X_6960_ _6966_/CLK _6960_/D VGND VGND VPWR VPWR _6960_/Q sky130_fd_sc_hd__dfxtp_2
XFILLER_81_548 VGND VGND VPWR VPWR sky130_fd_sc_hd__decap_3
XTAP_TAPCELL_ROW_49_798 VGND VPWR sky130_fd_sc_hd__tapvpwrvgnd_1
X_6891_ _6943_/CLK _6891_/D VGND VGND VPWR VPWR _6891_/Q sky130_fd_sc_hd__dfxtp_2
XFILLER_22_604 VGND VGND VPWR VPWR sky130_fd_sc_hd__decap_3
XFILLER_34_475 VGND VGND VPWR VPWR sky130_fd_sc_hd__fill_1
XFILLER_34_486 VGND VGND VPWR VPWR sky130_fd_sc_hd__fill_1
XFILLER_21_125 VGND VGND VPWR VPWR sky130_fd_sc_hd__decap_3
XFILLER_21_136 VGND VGND VPWR VPWR sky130_fd_sc_hd__decap_3
XFILLER_22_637 VGND VGND VPWR VPWR sky130_fd_sc_hd__decap_3
XTAP_TAPCELL_ROW_60_930 VGND VPWR sky130_fd_sc_hd__tapvpwrvgnd_1
XFILLER_21_169 VGND VGND VPWR VPWR sky130_fd_sc_hd__decap_3
X_4724_ _4720_/A _4655_/X _4658_/B VGND VGND VPWR VPWR _4724_/X sky130_fd_sc_hd__o21a_2
X_4655_ _4069_/Y _4765_/B _4611_/Y _4762_/A _4744_/B VGND VGND VPWR VPWR _4655_/X
+ sky130_fd_sc_hd__a221o_2
X_7374_ _7374_/CLK _7374_/D _6654_/Y VGND VGND VPWR VPWR _7374_/Q sky130_fd_sc_hd__dfrtp_2
Xhold800 _6792_/Q VGND VGND VPWR VPWR _6792_/D sky130_fd_sc_hd__dlygate4sd3_1
Xhold811 _6795_/Q VGND VGND VPWR VPWR _6795_/D sky130_fd_sc_hd__dlygate4sd3_1
X_3606_ _4614_/B _3603_/B _5146_/B1 VGND VGND VPWR VPWR _3606_/X sky130_fd_sc_hd__o21a_2
XFILLER_1_508 VGND VGND VPWR VPWR sky130_fd_sc_hd__decap_3
XFILLER_89_604 VGND VGND VPWR VPWR sky130_fd_sc_hd__decap_3
Xhold822 _6819_/Q VGND VGND VPWR VPWR _6819_/D sky130_fd_sc_hd__dlygate4sd3_1
Xhold833 _6804_/Q VGND VGND VPWR VPWR _6804_/D sky130_fd_sc_hd__dlygate4sd3_1
Xhold844 _7063_/Q VGND VGND VPWR VPWR _7063_/D sky130_fd_sc_hd__dlygate4sd3_1
Xhold855 _7073_/Q VGND VGND VPWR VPWR _7073_/D sky130_fd_sc_hd__dlygate4sd3_1
Xmax_cap563 _3469_/A VGND VGND VPWR VPWR _4217_/A1 sky130_fd_sc_hd__clkbuf_2
Xmax_cap552 _4069_/Y VGND VGND VPWR VPWR _4745_/A sky130_fd_sc_hd__clkbuf_2
X_6325_ _6669_/A VGND VGND VPWR VPWR _6325_/Y sky130_fd_sc_hd__inv_2
X_3537_ _3427_/B _3618_/C _5057_/A _3527_/A _3536_/Y VGND VGND VPWR VPWR _3537_/X
+ sky130_fd_sc_hd__o221a_2
XFILLER_107_25 VGND VGND VPWR VPWR sky130_fd_sc_hd__decap_3
Xhold866 _7084_/Q VGND VGND VPWR VPWR _7084_/D sky130_fd_sc_hd__dlygate4sd3_1
Xhold877 _7091_/Q VGND VGND VPWR VPWR _7091_/D sky130_fd_sc_hd__dlygate4sd3_1
Xhold888 _7078_/Q VGND VGND VPWR VPWR _7078_/D sky130_fd_sc_hd__dlygate4sd3_1
Xmax_cap574 _6344_/A VGND VGND VPWR VPWR _6678_/A sky130_fd_sc_hd__buf_2
XFILLER_107_69 VGND VGND VPWR VPWR sky130_fd_sc_hd__decap_3
XFILLER_88_125 VGND VGND VPWR VPWR sky130_fd_sc_hd__decap_3
Xhold899 _7107_/Q VGND VGND VPWR VPWR _7107_/D sky130_fd_sc_hd__dlygate4sd3_1
X_3468_ _7281_/Q _5142_/S _4335_/B1 _7089_/Q _3467_/X VGND VGND VPWR VPWR _3468_/X
+ sky130_fd_sc_hd__a221o_2
XFILLER_69_361 VGND VGND VPWR VPWR sky130_fd_sc_hd__decap_3
XFILLER_76_309 VGND VGND VPWR VPWR sky130_fd_sc_hd__decap_3
XFILLER_88_169 VGND VGND VPWR VPWR sky130_fd_sc_hd__decap_3
X_5207_ _5207_/A _5207_/B VGND VGND VPWR VPWR _7225_/D sky130_fd_sc_hd__and2_2
X_3399_ _3399_/A _3399_/B VGND VGND VPWR VPWR _3449_/B sky130_fd_sc_hd__nor2_4
XFILLER_29_225 VGND VGND VPWR VPWR sky130_fd_sc_hd__decap_3
XFILLER_57_545 VGND VGND VPWR VPWR sky130_fd_sc_hd__fill_1
X_5138_ _3665_/B _3914_/X _5138_/S VGND VGND VPWR VPWR _5138_/X sky130_fd_sc_hd__mux2_2
XFILLER_84_342 VGND VGND VPWR VPWR sky130_fd_sc_hd__decap_3
XFILLER_44_228 VGND VGND VPWR VPWR sky130_fd_sc_hd__fill_1
XFILLER_57_589 VGND VGND VPWR VPWR sky130_fd_sc_hd__decap_3
X_5069_ _6987_/Q _5069_/B VGND VGND VPWR VPWR _5069_/X sky130_fd_sc_hd__or2_2
XTAP_TAPCELL_ROW_67_1007 VGND VPWR sky130_fd_sc_hd__tapvpwrvgnd_1
XFILLER_25_442 VGND VGND VPWR VPWR sky130_fd_sc_hd__decap_3
XFILLER_13_615 VGND VGND VPWR VPWR sky130_fd_sc_hd__fill_1
XFILLER_13_626 VGND VGND VPWR VPWR sky130_fd_sc_hd__decap_3
XFILLER_25_475 VGND VGND VPWR VPWR sky130_fd_sc_hd__decap_3
XFILLER_16_88 VGND VGND VPWR VPWR sky130_fd_sc_hd__fill_1
XFILLER_52_283 VGND VGND VPWR VPWR sky130_fd_sc_hd__decap_3
XFILLER_80_592 VGND VGND VPWR VPWR sky130_fd_sc_hd__decap_3
XFILLER_12_147 VGND VGND VPWR VPWR sky130_fd_sc_hd__decap_3
XFILLER_32_32 VGND VGND VPWR VPWR sky130_fd_sc_hd__decap_3
XFILLER_20_180 VGND VGND VPWR VPWR sky130_fd_sc_hd__decap_3
XTAP_TAPCELL_ROW_78_1136 VGND VPWR sky130_fd_sc_hd__tapvpwrvgnd_1
XTAP_TAPCELL_ROW_10_348 VGND VPWR sky130_fd_sc_hd__tapvpwrvgnd_1
XFILLER_106_274 VGND VGND VPWR VPWR sky130_fd_sc_hd__decap_3
XFILLER_4_368 VGND VGND VPWR VPWR sky130_fd_sc_hd__fill_2
XFILLER_95_607 VGND VGND VPWR VPWR sky130_fd_sc_hd__decap_3
XFILLER_79_169 VGND VGND VPWR VPWR sky130_fd_sc_hd__decap_3
XFILLER_48_545 VGND VGND VPWR VPWR sky130_fd_sc_hd__fill_1
XFILLER_57_40 VGND VGND VPWR VPWR sky130_fd_sc_hd__decap_3
XFILLER_75_331 VGND VGND VPWR VPWR sky130_fd_sc_hd__decap_3
XTAP_TAPCELL_ROW_89_1254 VGND VPWR sky130_fd_sc_hd__tapvpwrvgnd_1
XFILLER_48_589 VGND VGND VPWR VPWR sky130_fd_sc_hd__decap_3
XFILLER_90_312 VGND VGND VPWR VPWR sky130_fd_sc_hd__decap_3
XFILLER_16_431 VGND VGND VPWR VPWR sky130_fd_sc_hd__fill_1
XFILLER_63_559 VGND VGND VPWR VPWR sky130_fd_sc_hd__fill_1
XFILLER_90_345 VGND VGND VPWR VPWR sky130_fd_sc_hd__decap_3
XTAP_TAPCELL_ROW_46_768 VGND VPWR sky130_fd_sc_hd__tapvpwrvgnd_1
XTAP_TAPCELL_ROW_18_437 VGND VPWR sky130_fd_sc_hd__tapvpwrvgnd_1
XFILLER_16_453 VGND VGND VPWR VPWR sky130_fd_sc_hd__decap_3
XFILLER_16_475 VGND VGND VPWR VPWR sky130_fd_sc_hd__fill_1
XFILLER_31_412 VGND VGND VPWR VPWR sky130_fd_sc_hd__decap_3
XFILLER_7_184 VGND VGND VPWR VPWR sky130_fd_sc_hd__decap_3
X_4440_ _4440_/A _4650_/B VGND VGND VPWR VPWR _4441_/B sky130_fd_sc_hd__nand2_2
X_4371_ _4371_/A _4371_/B VGND VGND VPWR VPWR _4371_/Y sky130_fd_sc_hd__nand2_2
XFILLER_98_80 VGND VGND VPWR VPWR sky130_fd_sc_hd__decap_3
XFILLER_98_401 VGND VGND VPWR VPWR sky130_fd_sc_hd__fill_1
XFILLER_3_390 VGND VGND VPWR VPWR sky130_fd_sc_hd__fill_2
X_7090_ _7348_/CLK _7090_/D _6370_/Y VGND VGND VPWR VPWR _7090_/Q sky130_fd_sc_hd__dfrtp_2
XFILLER_100_406 VGND VGND VPWR VPWR sky130_fd_sc_hd__decap_3
XFILLER_39_501 VGND VGND VPWR VPWR sky130_fd_sc_hd__decap_3
XFILLER_58_309 VGND VGND VPWR VPWR sky130_fd_sc_hd__decap_3
XFILLER_98_467 VGND VGND VPWR VPWR sky130_fd_sc_hd__decap_3
XFILLER_85_139 VGND VGND VPWR VPWR sky130_fd_sc_hd__decap_3
XFILLER_66_353 VGND VGND VPWR VPWR sky130_fd_sc_hd__fill_2
XFILLER_26_206 VGND VGND VPWR VPWR sky130_fd_sc_hd__decap_3
XFILLER_54_537 VGND VGND VPWR VPWR sky130_fd_sc_hd__decap_3
XFILLER_93_172 VGND VGND VPWR VPWR sky130_fd_sc_hd__decap_3
XFILLER_26_239 VGND VGND VPWR VPWR sky130_fd_sc_hd__decap_3
XFILLER_81_334 VGND VGND VPWR VPWR sky130_fd_sc_hd__fill_2
X_6943_ _6943_/CLK _6943_/D VGND VGND VPWR VPWR _6943_/Q sky130_fd_sc_hd__dfxtp_2
X_6874_ clkload9/A _6874_/D VGND VGND VPWR VPWR _6874_/Q sky130_fd_sc_hd__dfxtp_2
XFILLER_62_592 VGND VGND VPWR VPWR sky130_fd_sc_hd__fill_2
XFILLER_10_607 VGND VGND VPWR VPWR sky130_fd_sc_hd__decap_3
X_4707_ _6998_/Q _6999_/Q _7000_/Q _4912_/A VGND VGND VPWR VPWR _4825_/B sky130_fd_sc_hd__and4_2
X_4638_ _4950_/A _4950_/B VGND VGND VPWR VPWR _4948_/B sky130_fd_sc_hd__and2_2
Xhold630 _6723_/Q VGND VGND VPWR VPWR _6723_/D sky130_fd_sc_hd__dlygate4sd3_1
XFILLER_103_200 VGND VGND VPWR VPWR sky130_fd_sc_hd__decap_3
XFILLER_89_401 VGND VGND VPWR VPWR sky130_fd_sc_hd__decap_3
X_7357_ _7357_/CLK _7357_/D _6637_/Y VGND VGND VPWR VPWR _7357_/Q sky130_fd_sc_hd__dfrtp_2
Xhold641 _6845_/Q VGND VGND VPWR VPWR _6845_/D sky130_fd_sc_hd__dlygate4sd3_1
Xhold652 _6877_/Q VGND VGND VPWR VPWR _6877_/D sky130_fd_sc_hd__dlygate4sd3_1
Xhold663 _6912_/Q VGND VGND VPWR VPWR _6912_/D sky130_fd_sc_hd__dlygate4sd3_1
X_4569_ _4569_/A _4573_/B VGND VGND VPWR VPWR _7296_/D sky130_fd_sc_hd__and2_2
XFILLER_103_222 VGND VGND VPWR VPWR sky130_fd_sc_hd__fill_2
X_7288_ _7355_/CLK _7288_/D _6568_/Y VGND VGND VPWR VPWR _7288_/Q sky130_fd_sc_hd__dfrtp_2
Xhold674 _6753_/Q VGND VGND VPWR VPWR _6753_/D sky130_fd_sc_hd__dlygate4sd3_1
Xhold685 _6813_/Q VGND VGND VPWR VPWR _6813_/D sky130_fd_sc_hd__dlygate4sd3_1
Xhold696 _6838_/Q VGND VGND VPWR VPWR _6838_/D sky130_fd_sc_hd__dlygate4sd3_1
X_6308_ _6536_/A VGND VGND VPWR VPWR _6308_/Y sky130_fd_sc_hd__inv_2
XFILLER_77_629 VGND VGND VPWR VPWR sky130_fd_sc_hd__decap_3
XFILLER_89_489 VGND VGND VPWR VPWR sky130_fd_sc_hd__decap_3
XTAP_TAPCELL_ROW_73_1077 VGND VPWR sky130_fd_sc_hd__tapvpwrvgnd_1
XFILLER_103_299 VGND VGND VPWR VPWR sky130_fd_sc_hd__decap_3
XFILLER_94_27 VGND VGND VPWR VPWR sky130_fd_sc_hd__fill_1
XFILLER_69_191 VGND VGND VPWR VPWR sky130_fd_sc_hd__decap_3
XFILLER_17_228 VGND VGND VPWR VPWR sky130_fd_sc_hd__decap_3
XFILLER_72_312 VGND VGND VPWR VPWR sky130_fd_sc_hd__decap_3
XFILLER_84_172 VGND VGND VPWR VPWR sky130_fd_sc_hd__decap_3
XFILLER_27_87 VGND VGND VPWR VPWR sky130_fd_sc_hd__decap_3
XFILLER_45_548 VGND VGND VPWR VPWR sky130_fd_sc_hd__decap_3
XFILLER_32_209 VGND VGND VPWR VPWR sky130_fd_sc_hd__decap_3
XTAP_TAPCELL_ROW_15_407 VGND VPWR sky130_fd_sc_hd__tapvpwrvgnd_1
XFILLER_13_434 VGND VGND VPWR VPWR sky130_fd_sc_hd__decap_3
XFILLER_43_20 VGND VGND VPWR VPWR sky130_fd_sc_hd__decap_3
XFILLER_53_570 VGND VGND VPWR VPWR sky130_fd_sc_hd__decap_3
XFILLER_53_592 VGND VGND VPWR VPWR sky130_fd_sc_hd__decap_3
XTAP_TAPCELL_ROW_84_1195 VGND VPWR sky130_fd_sc_hd__tapvpwrvgnd_1
XTAP_TAPCELL_ROW_43_727 VGND VPWR sky130_fd_sc_hd__tapvpwrvgnd_1
XFILLER_40_253 VGND VGND VPWR VPWR sky130_fd_sc_hd__decap_3
XFILLER_9_427 VGND VGND VPWR VPWR sky130_fd_sc_hd__decap_3
XTAP_TAPCELL_ROW_23_495 VGND VPWR sky130_fd_sc_hd__tapvpwrvgnd_1
XFILLER_5_600 VGND VGND VPWR VPWR sky130_fd_sc_hd__decap_3
XFILLER_5_644 VGND VGND VPWR VPWR sky130_fd_sc_hd__decap_3
XFILLER_99_209 VGND VGND VPWR VPWR sky130_fd_sc_hd__fill_1
XFILLER_4_47 VGND VGND VPWR VPWR sky130_fd_sc_hd__fill_1
XFILLER_0_371 VGND VGND VPWR VPWR sky130_fd_sc_hd__decap_3
XFILLER_67_128 VGND VGND VPWR VPWR sky130_fd_sc_hd__fill_1
XFILLER_68_83 VGND VGND VPWR VPWR sky130_fd_sc_hd__fill_1
XFILLER_95_426 VGND VGND VPWR VPWR sky130_fd_sc_hd__decap_3
XFILLER_0_393 VGND VGND VPWR VPWR sky130_fd_sc_hd__decap_3
XFILLER_63_301 VGND VGND VPWR VPWR sky130_fd_sc_hd__fill_1
XFILLER_75_161 VGND VGND VPWR VPWR sky130_fd_sc_hd__decap_3
XFILLER_75_172 VGND VGND VPWR VPWR sky130_fd_sc_hd__decap_3
Xplace312 _4589_/B VGND VGND VPWR VPWR _4573_/B sky130_fd_sc_hd__buf_2
Xplace301 _4186_/Y VGND VGND VPWR VPWR _4950_/A sky130_fd_sc_hd__buf_2
Xplace345 _4272_/B VGND VGND VPWR VPWR _4394_/B sky130_fd_sc_hd__buf_2
Xplace334 _4214_/A2 VGND VGND VPWR VPWR _4430_/A2 sky130_fd_sc_hd__buf_2
Xplace323 _4205_/A VGND VGND VPWR VPWR _4432_/B1 sky130_fd_sc_hd__buf_2
XFILLER_44_570 VGND VGND VPWR VPWR sky130_fd_sc_hd__fill_1
XFILLER_90_175 VGND VGND VPWR VPWR sky130_fd_sc_hd__decap_3
Xplace378 _3874_/A VGND VGND VPWR VPWR _3423_/A sky130_fd_sc_hd__buf_2
Xplace389 _5628_/B VGND VGND VPWR VPWR _5633_/B sky130_fd_sc_hd__buf_2
Xplace367 _4248_/A VGND VGND VPWR VPWR _4338_/C1 sky130_fd_sc_hd__buf_2
Xplace356 _5063_/S VGND VGND VPWR VPWR _4352_/A2 sky130_fd_sc_hd__buf_2
X_3871_ _6785_/Q _3926_/B1 _3665_/X _6873_/Q VGND VGND VPWR VPWR _3871_/X sky130_fd_sc_hd__a22o_2
X_6590_ _6622_/A VGND VGND VPWR VPWR _6590_/Y sky130_fd_sc_hd__inv_2
XFILLER_31_297 VGND VGND VPWR VPWR sky130_fd_sc_hd__decap_3
X_7211_ _7405_/CLK _7211_/D _6491_/Y VGND VGND VPWR VPWR _7211_/Q sky130_fd_sc_hd__dfrtp_2
X_4423_ _7080_/Q _4102_/B _4432_/B1 _4422_/X VGND VGND VPWR VPWR _4649_/B sky130_fd_sc_hd__o211ai_2
X_7142_ _7366_/CLK _7142_/D _6422_/Y VGND VGND VPWR VPWR _7142_/Q sky130_fd_sc_hd__dfrtp_2
X_4354_ _7038_/Q _4244_/B _4354_/B1 _7385_/Q VGND VGND VPWR VPWR _4355_/B sky130_fd_sc_hd__a22o_2
XFILLER_59_629 VGND VGND VPWR VPWR sky130_fd_sc_hd__decap_3
X_7073_ _7397_/CLK _7073_/D _6353_/Y VGND VGND VPWR VPWR _7073_/Q sky130_fd_sc_hd__dfrtp_2
X_3305_ _6983_/Q VGND VGND VPWR VPWR _3340_/B sky130_fd_sc_hd__inv_2
XFILLER_98_253 VGND VGND VPWR VPWR sky130_fd_sc_hd__decap_3
XFILLER_100_203 VGND VGND VPWR VPWR sky130_fd_sc_hd__decap_3
XFILLER_86_448 VGND VGND VPWR VPWR sky130_fd_sc_hd__decap_3
X_4285_ _7035_/Q _3562_/A _4285_/B1 _7382_/Q VGND VGND VPWR VPWR _4286_/B sky130_fd_sc_hd__a22o_2
XFILLER_98_297 VGND VGND VPWR VPWR sky130_fd_sc_hd__decap_3
XFILLER_98_286 VGND VGND VPWR VPWR sky130_fd_sc_hd__decap_3
XFILLER_104_26 VGND VGND VPWR VPWR sky130_fd_sc_hd__fill_2
XFILLER_67_640 VGND VGND VPWR VPWR sky130_fd_sc_hd__decap_3
XFILLER_82_610 VGND VGND VPWR VPWR sky130_fd_sc_hd__decap_3
XFILLER_82_621 VGND VGND VPWR VPWR sky130_fd_sc_hd__fill_2
X_6926_ _6976_/CLK _6926_/D VGND VGND VPWR VPWR _6926_/Q sky130_fd_sc_hd__dfxtp_2
XFILLER_81_175 VGND VGND VPWR VPWR sky130_fd_sc_hd__decap_3
XFILLER_22_220 VGND VGND VPWR VPWR sky130_fd_sc_hd__decap_3
Xfanout24 _6598_/A VGND VGND VPWR VPWR _6628_/A sky130_fd_sc_hd__buf_2
Xfanout35 fanout48/X VGND VGND VPWR VPWR _6566_/A sky130_fd_sc_hd__clkbuf_2
Xfanout46 _6644_/A VGND VGND VPWR VPWR _6612_/A sky130_fd_sc_hd__buf_2
X_6857_ _6968_/CLK _6857_/D VGND VGND VPWR VPWR _6857_/Q sky130_fd_sc_hd__dfxtp_2
XFILLER_10_404 VGND VGND VPWR VPWR sky130_fd_sc_hd__decap_3
XFILLER_22_286 VGND VGND VPWR VPWR sky130_fd_sc_hd__decap_3
XFILLER_50_562 VGND VGND VPWR VPWR sky130_fd_sc_hd__decap_3
XFILLER_50_584 VGND VGND VPWR VPWR sky130_fd_sc_hd__fill_1
Xfanout57 fanout67/X VGND VGND VPWR VPWR _6686_/A sky130_fd_sc_hd__buf_2
Xfanout68 _6554_/A VGND VGND VPWR VPWR _6556_/A sky130_fd_sc_hd__buf_2
X_6788_ clkload8/A _6788_/D VGND VGND VPWR VPWR _6788_/Q sky130_fd_sc_hd__dfxtp_2
XFILLER_10_448 VGND VGND VPWR VPWR sky130_fd_sc_hd__decap_3
XFILLER_6_408 VGND VGND VPWR VPWR sky130_fd_sc_hd__decap_3
XTAP_TAPCELL_ROW_20_465 VGND VPWR sky130_fd_sc_hd__tapvpwrvgnd_1
XFILLER_1_113 VGND VGND VPWR VPWR sky130_fd_sc_hd__fill_1
XFILLER_2_625 VGND VGND VPWR VPWR sky130_fd_sc_hd__decap_3
XFILLER_89_231 VGND VGND VPWR VPWR sky130_fd_sc_hd__decap_3
XFILLER_104_542 VGND VGND VPWR VPWR sky130_fd_sc_hd__decap_3
XFILLER_1_146 VGND VGND VPWR VPWR sky130_fd_sc_hd__decap_3
XFILLER_89_264 VGND VGND VPWR VPWR sky130_fd_sc_hd__decap_3
XFILLER_104_586 VGND VGND VPWR VPWR sky130_fd_sc_hd__fill_2
XFILLER_49_139 VGND VGND VPWR VPWR sky130_fd_sc_hd__decap_3
XFILLER_58_640 VGND VGND VPWR VPWR sky130_fd_sc_hd__decap_3
XFILLER_92_407 VGND VGND VPWR VPWR sky130_fd_sc_hd__decap_3
XFILLER_38_64 VGND VGND VPWR VPWR sky130_fd_sc_hd__decap_3
XFILLER_45_312 VGND VGND VPWR VPWR sky130_fd_sc_hd__decap_3
XFILLER_73_610 VGND VGND VPWR VPWR sky130_fd_sc_hd__fill_1
XFILLER_92_429 VGND VGND VPWR VPWR sky130_fd_sc_hd__decap_3
Xhold1160 _7162_/Q VGND VGND VPWR VPWR _5338_/A0 sky130_fd_sc_hd__dlygate4sd3_1
XFILLER_45_334 VGND VGND VPWR VPWR sky130_fd_sc_hd__fill_2
XFILLER_57_194 VGND VGND VPWR VPWR sky130_fd_sc_hd__decap_3
XFILLER_85_492 VGND VGND VPWR VPWR sky130_fd_sc_hd__decap_3
Xhold1171 _7153_/Q VGND VGND VPWR VPWR _5356_/A0 sky130_fd_sc_hd__dlygate4sd3_1
Xhold1182 _7333_/Q VGND VGND VPWR VPWR _4493_/A0 sky130_fd_sc_hd__dlygate4sd3_1
Xhold1193 _7172_/Q VGND VGND VPWR VPWR _5317_/A0 sky130_fd_sc_hd__dlygate4sd3_1
XTAP_TAPCELL_ROW_86_1224 VGND VPWR sky130_fd_sc_hd__tapvpwrvgnd_1
XFILLER_33_518 VGND VGND VPWR VPWR sky130_fd_sc_hd__decap_3
XFILLER_45_367 VGND VGND VPWR VPWR sky130_fd_sc_hd__decap_3
XTAP_TAPCELL_ROW_56_874 VGND VPWR sky130_fd_sc_hd__tapvpwrvgnd_1
XTAP_TAPCELL_ROW_28_554 VGND VPWR sky130_fd_sc_hd__tapvpwrvgnd_1
XFILLER_26_581 VGND VGND VPWR VPWR sky130_fd_sc_hd__decap_3
XFILLER_45_389 VGND VGND VPWR VPWR sky130_fd_sc_hd__decap_3
XFILLER_54_74 VGND VGND VPWR VPWR sky130_fd_sc_hd__fill_2
XFILLER_72_175 VGND VGND VPWR VPWR sky130_fd_sc_hd__decap_3
XFILLER_72_197 VGND VGND VPWR VPWR sky130_fd_sc_hd__decap_3
XFILLER_13_231 VGND VGND VPWR VPWR sky130_fd_sc_hd__decap_3
XFILLER_41_551 VGND VGND VPWR VPWR sky130_fd_sc_hd__fill_2
XFILLER_54_85 VGND VGND VPWR VPWR sky130_fd_sc_hd__decap_3
XFILLER_9_202 VGND VGND VPWR VPWR sky130_fd_sc_hd__decap_3
XFILLER_13_297 VGND VGND VPWR VPWR sky130_fd_sc_hd__fill_2
XFILLER_9_246 VGND VGND VPWR VPWR sky130_fd_sc_hd__fill_1
Xclkload16 _7376_/CLK VGND VGND VPWR VPWR clkload16/X sky130_fd_sc_hd__clkbuf_1
Xclkload27 _7083_/CLK VGND VGND VPWR VPWR clkload27/Y sky130_fd_sc_hd__inv_8
XTAP_TAPCELL_ROW_97_1353 VGND VPWR sky130_fd_sc_hd__tapvpwrvgnd_1
XFILLER_107_380 VGND VGND VPWR VPWR sky130_fd_sc_hd__fill_1
XFILLER_79_93 VGND VGND VPWR VPWR sky130_fd_sc_hd__fill_2
XFILLER_95_201 VGND VGND VPWR VPWR sky130_fd_sc_hd__decap_3
X_4070_ _7339_/Q _3939_/S _4420_/B1 _7147_/Q VGND VGND VPWR VPWR _4070_/X sky130_fd_sc_hd__a22o_2
XFILLER_48_150 VGND VGND VPWR VPWR sky130_fd_sc_hd__decap_3
XFILLER_48_161 VGND VGND VPWR VPWR sky130_fd_sc_hd__decap_3
XFILLER_83_418 VGND VGND VPWR VPWR sky130_fd_sc_hd__decap_3
XFILLER_48_194 VGND VGND VPWR VPWR sky130_fd_sc_hd__fill_2
XFILLER_64_632 VGND VGND VPWR VPWR sky130_fd_sc_hd__decap_3
XFILLER_76_492 VGND VGND VPWR VPWR sky130_fd_sc_hd__decap_3
XFILLER_24_507 VGND VGND VPWR VPWR sky130_fd_sc_hd__decap_3
XFILLER_91_473 VGND VGND VPWR VPWR sky130_fd_sc_hd__decap_3
XFILLER_51_337 VGND VGND VPWR VPWR sky130_fd_sc_hd__decap_3
XFILLER_91_484 VGND VGND VPWR VPWR sky130_fd_sc_hd__decap_3
X_4972_ _5661_/B VGND VGND VPWR VPWR _4973_/B sky130_fd_sc_hd__inv_2
X_6711_ _7083_/CLK _6711_/D VGND VGND VPWR VPWR _6711_/Q sky130_fd_sc_hd__dfxtp_2
X_3923_ _3927_/A1 _3922_/X _3874_/A VGND VGND VPWR VPWR _3923_/X sky130_fd_sc_hd__a21o_2
X_6642_ _6642_/A VGND VGND VPWR VPWR _6642_/Y sky130_fd_sc_hd__inv_2
X_3854_ _3725_/X _3851_/X _3853_/X _3735_/X VGND VGND VPWR VPWR _3854_/X sky130_fd_sc_hd__a22o_2
XFILLER_32_595 VGND VGND VPWR VPWR sky130_fd_sc_hd__decap_3
X_6573_ _6638_/A VGND VGND VPWR VPWR _6573_/Y sky130_fd_sc_hd__inv_2
X_3785_ _6837_/Q _3853_/A2 _3656_/Y _6832_/Q _3784_/X VGND VGND VPWR VPWR _3785_/X
+ sky130_fd_sc_hd__a221o_2
XFILLER_8_290 VGND VGND VPWR VPWR sky130_fd_sc_hd__decap_3
Xoutput510 _5642_/A VGND VGND VPWR VPWR instruction_out[3] sky130_fd_sc_hd__clkdlybuf4s25_1
Xoutput543 _5135_/A1 VGND VGND VPWR VPWR pc_out[4] sky130_fd_sc_hd__clkdlybuf4s25_1
Xoutput532 _7000_/Q VGND VGND VPWR VPWR pc_out[23] sky130_fd_sc_hd__clkdlybuf4s25_1
Xoutput521 _6990_/Q VGND VGND VPWR VPWR pc_out[13] sky130_fd_sc_hd__clkdlybuf4s25_1
X_4406_ _7402_/Q _4437_/B1 _4434_/B1 _7146_/Q _4405_/X VGND VGND VPWR VPWR _4406_/X
+ sky130_fd_sc_hd__a221o_2
X_7125_ _7349_/CLK _7125_/D _6405_/Y VGND VGND VPWR VPWR _7125_/Q sky130_fd_sc_hd__dfrtp_2
X_5386_ _5386_/A0 _4899_/X _5400_/S VGND VGND VPWR VPWR _7140_/D sky130_fd_sc_hd__mux2_2
XFILLER_99_551 VGND VGND VPWR VPWR sky130_fd_sc_hd__decap_3
X_4337_ _4394_/A _4337_/B _4336_/X VGND VGND VPWR VPWR _4365_/C sky130_fd_sc_hd__or3b_2
XTAP_TAPCELL_ROW_70_1036 VGND VPWR sky130_fd_sc_hd__tapvpwrvgnd_1
XFILLER_101_567 VGND VGND VPWR VPWR sky130_fd_sc_hd__decap_3
XFILLER_86_245 VGND VGND VPWR VPWR sky130_fd_sc_hd__decap_3
X_7056_ _7382_/CLK _7056_/D _6336_/Y VGND VGND VPWR VPWR _7056_/Q sky130_fd_sc_hd__dfstp_2
X_4268_ _7198_/Q _3966_/S _4354_/B1 _7390_/Q VGND VGND VPWR VPWR _4268_/X sky130_fd_sc_hd__a22o_2
XFILLER_27_301 VGND VGND VPWR VPWR sky130_fd_sc_hd__decap_3
XFILLER_39_161 VGND VGND VPWR VPWR sky130_fd_sc_hd__decap_3
XFILLER_55_610 VGND VGND VPWR VPWR sky130_fd_sc_hd__decap_3
XFILLER_86_289 VGND VGND VPWR VPWR sky130_fd_sc_hd__fill_1
XFILLER_39_172 VGND VGND VPWR VPWR sky130_fd_sc_hd__decap_3
XFILLER_55_632 VGND VGND VPWR VPWR sky130_fd_sc_hd__decap_3
X_4199_ _4380_/A _4380_/B VGND VGND VPWR VPWR _4381_/A sky130_fd_sc_hd__nand2_2
XFILLER_27_345 VGND VGND VPWR VPWR sky130_fd_sc_hd__decap_3
XFILLER_27_378 VGND VGND VPWR VPWR sky130_fd_sc_hd__fill_1
XFILLER_54_153 VGND VGND VPWR VPWR sky130_fd_sc_hd__decap_3
XFILLER_54_197 VGND VGND VPWR VPWR sky130_fd_sc_hd__decap_3
XFILLER_70_613 VGND VGND VPWR VPWR sky130_fd_sc_hd__decap_3
XFILLER_91_28 VGND VGND VPWR VPWR sky130_fd_sc_hd__decap_3
XTAP_TAPCELL_ROW_25_524 VGND VPWR sky130_fd_sc_hd__tapvpwrvgnd_1
X_6909_ clkload7/A _6909_/D VGND VGND VPWR VPWR _6909_/Q sky130_fd_sc_hd__dfxtp_2
XTAP_TAPCELL_ROW_53_844 VGND VPWR sky130_fd_sc_hd__tapvpwrvgnd_1
XFILLER_23_573 VGND VGND VPWR VPWR sky130_fd_sc_hd__fill_1
XTAP_TAPCELL_ROW_81_1165 VGND VPWR sky130_fd_sc_hd__tapvpwrvgnd_1
XFILLER_10_212 VGND VGND VPWR VPWR sky130_fd_sc_hd__decap_3
XFILLER_23_595 VGND VGND VPWR VPWR sky130_fd_sc_hd__decap_3
XFILLER_24_88 VGND VGND VPWR VPWR sky130_fd_sc_hd__decap_3
XFILLER_10_256 VGND VGND VPWR VPWR sky130_fd_sc_hd__decap_3
XFILLER_108_155 VGND VGND VPWR VPWR sky130_fd_sc_hd__decap_3
XFILLER_108_177 VGND VGND VPWR VPWR sky130_fd_sc_hd__decap_3
XFILLER_104_350 VGND VGND VPWR VPWR sky130_fd_sc_hd__decap_3
XFILLER_104_383 VGND VGND VPWR VPWR sky130_fd_sc_hd__decap_3
XFILLER_49_41 VGND VGND VPWR VPWR sky130_fd_sc_hd__fill_2
XFILLER_77_223 VGND VGND VPWR VPWR sky130_fd_sc_hd__fill_1
XTAP_TAPCELL_ROW_92_1294 VGND VPWR sky130_fd_sc_hd__tapvpwrvgnd_1
XFILLER_77_234 VGND VGND VPWR VPWR sky130_fd_sc_hd__decap_3
XFILLER_1_15 VGND VGND VPWR VPWR sky130_fd_sc_hd__decap_3
XFILLER_18_334 VGND VGND VPWR VPWR sky130_fd_sc_hd__decap_3
XFILLER_46_632 VGND VGND VPWR VPWR sky130_fd_sc_hd__decap_3
XFILLER_92_237 VGND VGND VPWR VPWR sky130_fd_sc_hd__decap_3
XTAP_TAPCELL_ROW_5_293 VGND VPWR sky130_fd_sc_hd__tapvpwrvgnd_1
XFILLER_45_131 VGND VGND VPWR VPWR sky130_fd_sc_hd__decap_3
XFILLER_61_602 VGND VGND VPWR VPWR sky130_fd_sc_hd__fill_1
XFILLER_65_84 VGND VGND VPWR VPWR sky130_fd_sc_hd__decap_3
XFILLER_61_635 VGND VGND VPWR VPWR sky130_fd_sc_hd__decap_3
XFILLER_33_348 VGND VGND VPWR VPWR sky130_fd_sc_hd__decap_3
XFILLER_45_197 VGND VGND VPWR VPWR sky130_fd_sc_hd__decap_3
XFILLER_14_595 VGND VGND VPWR VPWR sky130_fd_sc_hd__decap_3
XFILLER_41_381 VGND VGND VPWR VPWR sky130_fd_sc_hd__fill_2
X_3570_ _7157_/Q _3409_/X _4288_/B _3469_/B _3469_/A VGND VGND VPWR VPWR _3570_/X
+ sky130_fd_sc_hd__a2111o_2
XFILLER_5_260 VGND VGND VPWR VPWR sky130_fd_sc_hd__decap_3
X_5240_ _4788_/A _4788_/B _5238_/X _5240_/B2 VGND VGND VPWR VPWR _7210_/D sky130_fd_sc_hd__a22o_2
XFILLER_102_309 VGND VGND VPWR VPWR sky130_fd_sc_hd__decap_3
XFILLER_68_212 VGND VGND VPWR VPWR sky130_fd_sc_hd__decap_3
X_5171_ _5171_/A _5186_/B VGND VGND VPWR VPWR _7242_/D sky130_fd_sc_hd__and2_2
XPHY_EDGE_ROW_18_Right_18 VGND VGND VPWR VPWR sky130_fd_sc_hd__decap_3
XFILLER_68_256 VGND VGND VPWR VPWR sky130_fd_sc_hd__decap_3
X_4122_ _7204_/Q _3956_/S _4429_/A2 _7049_/Q _4121_/X VGND VGND VPWR VPWR _4122_/X
+ sky130_fd_sc_hd__a221o_2
XFILLER_37_610 VGND VGND VPWR VPWR sky130_fd_sc_hd__decap_3
X_4053_ _4054_/A _4456_/A VGND VGND VPWR VPWR _4055_/A sky130_fd_sc_hd__nor2_2
XFILLER_37_632 VGND VGND VPWR VPWR sky130_fd_sc_hd__decap_3
XFILLER_49_492 VGND VGND VPWR VPWR sky130_fd_sc_hd__decap_3
XFILLER_83_237 VGND VGND VPWR VPWR sky130_fd_sc_hd__decap_3
XFILLER_36_153 VGND VGND VPWR VPWR sky130_fd_sc_hd__decap_3
XFILLER_36_186 VGND VGND VPWR VPWR sky130_fd_sc_hd__decap_3
XFILLER_51_101 VGND VGND VPWR VPWR sky130_fd_sc_hd__decap_3
XFILLER_52_624 VGND VGND VPWR VPWR sky130_fd_sc_hd__decap_3
XFILLER_91_270 VGND VGND VPWR VPWR sky130_fd_sc_hd__decap_3
XFILLER_91_281 VGND VGND VPWR VPWR sky130_fd_sc_hd__fill_1
XFILLER_101_27 VGND VGND VPWR VPWR sky130_fd_sc_hd__fill_1
XFILLER_24_348 VGND VGND VPWR VPWR sky130_fd_sc_hd__decap_3
XFILLER_36_197 VGND VGND VPWR VPWR sky130_fd_sc_hd__decap_3
XFILLER_51_145 VGND VGND VPWR VPWR sky130_fd_sc_hd__fill_2
X_4955_ _5006_/A1 _4639_/A _4950_/A _5033_/B2 VGND VGND VPWR VPWR _4955_/X sky130_fd_sc_hd__a22o_2
XPHY_EDGE_ROW_27_Right_27 VGND VGND VPWR VPWR sky130_fd_sc_hd__decap_3
XFILLER_51_178 VGND VGND VPWR VPWR sky130_fd_sc_hd__decap_3
X_3906_ _6917_/Q _3926_/A2 _5660_/B _6691_/Q VGND VGND VPWR VPWR _3906_/X sky130_fd_sc_hd__a22o_2
XTAP_TAPCELL_ROW_50_814 VGND VPWR sky130_fd_sc_hd__tapvpwrvgnd_1
XFILLER_32_381 VGND VGND VPWR VPWR sky130_fd_sc_hd__decap_3
X_4886_ _4886_/A _4890_/B _4886_/C VGND VGND VPWR VPWR _4886_/X sky130_fd_sc_hd__or3_2
X_6625_ _6625_/A VGND VGND VPWR VPWR _6625_/Y sky130_fd_sc_hd__inv_2
X_3837_ _6755_/Q _3887_/A2 _3887_/B1 _6767_/Q VGND VGND VPWR VPWR _3837_/X sky130_fd_sc_hd__a22o_2
XFILLER_20_598 VGND VGND VPWR VPWR sky130_fd_sc_hd__decap_3
X_6556_ _6556_/A VGND VGND VPWR VPWR _6556_/Y sky130_fd_sc_hd__inv_2
X_3768_ _6931_/Q _3912_/A2 _3913_/A2 _6795_/Q VGND VGND VPWR VPWR _3768_/X sky130_fd_sc_hd__a22o_2
XTAP_TAPCELL_ROW_30_582 VGND VPWR sky130_fd_sc_hd__tapvpwrvgnd_1
XFILLER_106_604 VGND VGND VPWR VPWR sky130_fd_sc_hd__decap_3
XFILLER_3_219 VGND VGND VPWR VPWR sky130_fd_sc_hd__decap_3
X_6487_ _6652_/A VGND VGND VPWR VPWR _6487_/Y sky130_fd_sc_hd__inv_2
X_3699_ _6713_/Q _3823_/A2 _3883_/B1 _6891_/Q VGND VGND VPWR VPWR _3699_/X sky130_fd_sc_hd__a22o_2
XFILLER_105_169 VGND VGND VPWR VPWR sky130_fd_sc_hd__decap_3
XPHY_EDGE_ROW_36_Right_36 VGND VGND VPWR VPWR sky130_fd_sc_hd__decap_3
X_5369_ _5369_/A0 _4752_/X _5388_/S VGND VGND VPWR VPWR _7148_/D sky130_fd_sc_hd__mux2_2
XFILLER_101_331 VGND VGND VPWR VPWR sky130_fd_sc_hd__decap_3
X_7108_ _7361_/CLK _7108_/D _6388_/Y VGND VGND VPWR VPWR _7108_/Q sky130_fd_sc_hd__dfrtp_2
XFILLER_101_364 VGND VGND VPWR VPWR sky130_fd_sc_hd__decap_3
XFILLER_19_44 VGND VGND VPWR VPWR sky130_fd_sc_hd__decap_3
X_7039_ _7398_/CLK _7039_/D _6319_/Y VGND VGND VPWR VPWR _7039_/Q sky130_fd_sc_hd__dfrtp_2
XTAP_TAPCELL_ROW_58_903 VGND VPWR sky130_fd_sc_hd__tapvpwrvgnd_1
XFILLER_19_66 VGND VGND VPWR VPWR sky130_fd_sc_hd__decap_3
XFILLER_28_610 VGND VGND VPWR VPWR sky130_fd_sc_hd__decap_3
XFILLER_28_643 VGND VGND VPWR VPWR sky130_fd_sc_hd__fill_1
XTAP_TAPCELL_ROW_2_263 VGND VPWR sky130_fd_sc_hd__tapvpwrvgnd_1
XTAP_TAPCELL_ROW_2_252 VGND VPWR sky130_fd_sc_hd__tapvpwrvgnd_1
XFILLER_43_635 VGND VGND VPWR VPWR sky130_fd_sc_hd__decap_3
XFILLER_70_410 VGND VGND VPWR VPWR sky130_fd_sc_hd__decap_3
XFILLER_70_421 VGND VGND VPWR VPWR sky130_fd_sc_hd__decap_3
XTAP_TAPCELL_ROW_66_991 VGND VPWR sky130_fd_sc_hd__tapvpwrvgnd_1
XTAP_TAPCELL_ROW_38_671 VGND VPWR sky130_fd_sc_hd__tapvpwrvgnd_1
XPHY_EDGE_ROW_45_Right_45 VGND VGND VPWR VPWR sky130_fd_sc_hd__decap_3
XFILLER_15_337 VGND VGND VPWR VPWR sky130_fd_sc_hd__decap_3
XFILLER_35_65 VGND VGND VPWR VPWR sky130_fd_sc_hd__decap_3
XFILLER_42_123 VGND VGND VPWR VPWR sky130_fd_sc_hd__decap_3
XFILLER_70_443 VGND VGND VPWR VPWR sky130_fd_sc_hd__decap_3
XFILLER_82_292 VGND VGND VPWR VPWR sky130_fd_sc_hd__decap_3
XFILLER_30_329 VGND VGND VPWR VPWR sky130_fd_sc_hd__fill_2
XFILLER_70_498 VGND VGND VPWR VPWR sky130_fd_sc_hd__fill_1
XFILLER_11_543 VGND VGND VPWR VPWR sky130_fd_sc_hd__decap_3
XFILLER_11_576 VGND VGND VPWR VPWR sky130_fd_sc_hd__decap_3
XFILLER_51_53 VGND VGND VPWR VPWR sky130_fd_sc_hd__decap_3
XFILLER_7_525 VGND VGND VPWR VPWR sky130_fd_sc_hd__decap_3
XFILLER_7_558 VGND VGND VPWR VPWR sky130_fd_sc_hd__fill_2
XTAP_TAPCELL_ROW_94_1312 VGND VPWR sky130_fd_sc_hd__tapvpwrvgnd_1
XPHY_EDGE_ROW_54_Right_54 VGND VGND VPWR VPWR sky130_fd_sc_hd__decap_3
XPHY_EDGE_ROW_29_Left_138 VGND VGND VPWR VPWR sky130_fd_sc_hd__decap_3
XFILLER_104_180 VGND VGND VPWR VPWR sky130_fd_sc_hd__decap_3
XFILLER_78_543 VGND VGND VPWR VPWR sky130_fd_sc_hd__decap_3
XFILLER_93_513 VGND VGND VPWR VPWR sky130_fd_sc_hd__fill_1
XFILLER_19_632 VGND VGND VPWR VPWR sky130_fd_sc_hd__decap_3
XFILLER_18_120 VGND VGND VPWR VPWR sky130_fd_sc_hd__decap_3
XPHY_EDGE_ROW_63_Right_63 VGND VGND VPWR VPWR sky130_fd_sc_hd__decap_3
XFILLER_18_153 VGND VGND VPWR VPWR sky130_fd_sc_hd__fill_2
XFILLER_18_186 VGND VGND VPWR VPWR sky130_fd_sc_hd__decap_3
XFILLER_34_635 VGND VGND VPWR VPWR sky130_fd_sc_hd__decap_3
XFILLER_46_462 VGND VGND VPWR VPWR sky130_fd_sc_hd__decap_3
XFILLER_46_484 VGND VGND VPWR VPWR sky130_fd_sc_hd__decap_3
XFILLER_80_218 VGND VGND VPWR VPWR sky130_fd_sc_hd__decap_3
XFILLER_61_421 VGND VGND VPWR VPWR sky130_fd_sc_hd__decap_3
XFILLER_73_281 VGND VGND VPWR VPWR sky130_fd_sc_hd__decap_3
XPHY_EDGE_ROW_1_Left_110 VGND VGND VPWR VPWR sky130_fd_sc_hd__decap_3
XPHY_EDGE_ROW_38_Left_147 VGND VGND VPWR VPWR sky130_fd_sc_hd__decap_3
XFILLER_21_329 VGND VGND VPWR VPWR sky130_fd_sc_hd__decap_3
XFILLER_33_189 VGND VGND VPWR VPWR sky130_fd_sc_hd__decap_3
X_4740_ _4745_/A _4765_/B _4611_/Y _4762_/A _4948_/A VGND VGND VPWR VPWR _4740_/X
+ sky130_fd_sc_hd__a221o_2
X_4671_ _6991_/Q _5628_/B VGND VGND VPWR VPWR _4982_/B sky130_fd_sc_hd__and2_2
X_7390_ _7398_/CLK _7390_/D _6670_/Y VGND VGND VPWR VPWR _7390_/Q sky130_fd_sc_hd__dfrtp_2
X_6410_ _6638_/A VGND VGND VPWR VPWR _6410_/Y sky130_fd_sc_hd__inv_2
X_3622_ _4852_/A _5057_/A VGND VGND VPWR VPWR _3635_/B sky130_fd_sc_hd__nand2_2
X_6341_ _6630_/A VGND VGND VPWR VPWR _6341_/Y sky130_fd_sc_hd__inv_2
XPHY_EDGE_ROW_72_Right_72 VGND VGND VPWR VPWR sky130_fd_sc_hd__decap_3
X_3553_ _3469_/A _3469_/B _3449_/A _7253_/Q _3365_/A VGND VGND VPWR VPWR _3553_/X
+ sky130_fd_sc_hd__o2111a_2
X_6272_ _6554_/A VGND VGND VPWR VPWR _6272_/Y sky130_fd_sc_hd__inv_2
X_3484_ _4394_/A _4288_/B _3482_/Y _5153_/B VGND VGND VPWR VPWR _3485_/C sky130_fd_sc_hd__o31a_2
XPHY_EDGE_ROW_47_Left_156 VGND VGND VPWR VPWR sky130_fd_sc_hd__decap_3
XFILLER_103_629 VGND VGND VPWR VPWR sky130_fd_sc_hd__decap_3
X_5223_ _5223_/A _5223_/B VGND VGND VPWR VPWR _7217_/D sky130_fd_sc_hd__and2_2
X_5154_ _5152_/Y _5153_/X _5587_/B VGND VGND VPWR VPWR _5154_/Y sky130_fd_sc_hd__a21oi_2
XFILLER_29_418 VGND VGND VPWR VPWR sky130_fd_sc_hd__fill_1
XFILLER_56_204 VGND VGND VPWR VPWR sky130_fd_sc_hd__decap_3
X_4105_ _7205_/Q _3945_/S _4399_/A2 _7397_/Q _4104_/X VGND VGND VPWR VPWR _4105_/X
+ sky130_fd_sc_hd__a221o_2
XFILLER_96_362 VGND VGND VPWR VPWR sky130_fd_sc_hd__fill_2
XFILLER_56_226 VGND VGND VPWR VPWR sky130_fd_sc_hd__decap_3
X_5085_ _5086_/A _5085_/A2 _5084_/X VGND VGND VPWR VPWR _5085_/X sky130_fd_sc_hd__o21ba_2
XPHY_EDGE_ROW_81_Right_81 VGND VGND VPWR VPWR sky130_fd_sc_hd__decap_3
X_4036_ _7310_/Q _4865_/S _4434_/A2 _7118_/Q _4035_/X VGND VGND VPWR VPWR _4036_/X
+ sky130_fd_sc_hd__a221o_2
XFILLER_24_134 VGND VGND VPWR VPWR sky130_fd_sc_hd__decap_3
XFILLER_25_635 VGND VGND VPWR VPWR sky130_fd_sc_hd__decap_3
XFILLER_52_421 VGND VGND VPWR VPWR sky130_fd_sc_hd__decap_3
XFILLER_52_443 VGND VGND VPWR VPWR sky130_fd_sc_hd__decap_3
XTAP_TAPCELL_ROW_35_641 VGND VPWR sky130_fd_sc_hd__tapvpwrvgnd_1
XPHY_EDGE_ROW_56_Left_165 VGND VGND VPWR VPWR sky130_fd_sc_hd__decap_3
XFILLER_40_627 VGND VGND VPWR VPWR sky130_fd_sc_hd__decap_3
XFILLER_52_487 VGND VGND VPWR VPWR sky130_fd_sc_hd__decap_3
XTAP_TAPCELL_ROW_63_961 VGND VPWR sky130_fd_sc_hd__tapvpwrvgnd_1
X_4938_ _4938_/A _4938_/B VGND VGND VPWR VPWR _4938_/Y sky130_fd_sc_hd__nor2_2
X_4869_ _6999_/Q _4858_/B _4777_/A VGND VGND VPWR VPWR _4870_/B sky130_fd_sc_hd__o21ai_2
X_6608_ _6608_/A VGND VGND VPWR VPWR _6608_/Y sky130_fd_sc_hd__inv_2
XPHY_EDGE_ROW_90_Right_90 VGND VGND VPWR VPWR sky130_fd_sc_hd__decap_3
XFILLER_4_506 VGND VGND VPWR VPWR sky130_fd_sc_hd__decap_3
X_6539_ _6636_/A VGND VGND VPWR VPWR _6539_/Y sky130_fd_sc_hd__inv_2
XPHY_EDGE_ROW_65_Left_174 VGND VGND VPWR VPWR sky130_fd_sc_hd__decap_3
XTAP_TAPCELL_ROW_7_311 VGND VPWR sky130_fd_sc_hd__tapvpwrvgnd_1
XFILLER_87_340 VGND VGND VPWR VPWR sky130_fd_sc_hd__decap_3
XFILLER_87_362 VGND VGND VPWR VPWR sky130_fd_sc_hd__decap_3
XFILLER_101_172 VGND VGND VPWR VPWR sky130_fd_sc_hd__decap_3
XFILLER_75_546 VGND VGND VPWR VPWR sky130_fd_sc_hd__fill_2
XFILLER_47_259 VGND VGND VPWR VPWR sky130_fd_sc_hd__decap_3
XFILLER_75_568 VGND VGND VPWR VPWR sky130_fd_sc_hd__decap_3
XFILLER_16_613 VGND VGND VPWR VPWR sky130_fd_sc_hd__decap_3
XPHY_EDGE_ROW_74_Left_183 VGND VGND VPWR VPWR sky130_fd_sc_hd__decap_3
XFILLER_15_123 VGND VGND VPWR VPWR sky130_fd_sc_hd__decap_3
XFILLER_55_281 VGND VGND VPWR VPWR sky130_fd_sc_hd__decap_3
XFILLER_15_167 VGND VGND VPWR VPWR sky130_fd_sc_hd__fill_1
XFILLER_30_126 VGND VGND VPWR VPWR sky130_fd_sc_hd__decap_3
XFILLER_31_638 VGND VGND VPWR VPWR sky130_fd_sc_hd__decap_3
XFILLER_11_340 VGND VGND VPWR VPWR sky130_fd_sc_hd__decap_3
XFILLER_62_85 VGND VGND VPWR VPWR sky130_fd_sc_hd__fill_1
XFILLER_7_300 VGND VGND VPWR VPWR sky130_fd_sc_hd__decap_3
XFILLER_7_322 VGND VGND VPWR VPWR sky130_fd_sc_hd__decap_3
XTAP_TAPCELL_ROW_13_379 VGND VPWR sky130_fd_sc_hd__tapvpwrvgnd_1
XPHY_EDGE_ROW_83_Left_192 VGND VGND VPWR VPWR sky130_fd_sc_hd__decap_3
XFILLER_3_550 VGND VGND VPWR VPWR sky130_fd_sc_hd__decap_3
XFILLER_3_561 VGND VGND VPWR VPWR sky130_fd_sc_hd__decap_3
XFILLER_3_594 VGND VGND VPWR VPWR sky130_fd_sc_hd__decap_3
XFILLER_87_60 VGND VGND VPWR VPWR sky130_fd_sc_hd__fill_1
XFILLER_66_502 VGND VGND VPWR VPWR sky130_fd_sc_hd__fill_1
XFILLER_78_362 VGND VGND VPWR VPWR sky130_fd_sc_hd__fill_2
XFILLER_38_259 VGND VGND VPWR VPWR sky130_fd_sc_hd__decap_3
XFILLER_81_505 VGND VGND VPWR VPWR sky130_fd_sc_hd__decap_3
XFILLER_93_343 VGND VGND VPWR VPWR sky130_fd_sc_hd__decap_3
XTAP_TAPCELL_ROW_49_799 VGND VPWR sky130_fd_sc_hd__tapvpwrvgnd_1
XFILLER_34_421 VGND VGND VPWR VPWR sky130_fd_sc_hd__decap_3
X_6890_ _6966_/CLK _6890_/D VGND VGND VPWR VPWR _6890_/Q sky130_fd_sc_hd__dfxtp_2
XFILLER_22_616 VGND VGND VPWR VPWR sky130_fd_sc_hd__decap_3
XFILLER_61_273 VGND VGND VPWR VPWR sky130_fd_sc_hd__decap_3
XTAP_TAPCELL_ROW_60_920 VGND VPWR sky130_fd_sc_hd__tapvpwrvgnd_1
XTAP_TAPCELL_ROW_32_600 VGND VPWR sky130_fd_sc_hd__tapvpwrvgnd_1
XFILLER_21_148 VGND VGND VPWR VPWR sky130_fd_sc_hd__decap_3
X_4723_ _3536_/B _4720_/A _4721_/Y _5006_/A1 VGND VGND VPWR VPWR _4723_/X sky130_fd_sc_hd__a22o_2
X_4654_ _4646_/Y _4647_/X _4653_/Y _4788_/B VGND VGND VPWR VPWR _4762_/A sky130_fd_sc_hd__a211o_2
X_7373_ _7373_/CLK _7373_/D _6653_/Y VGND VGND VPWR VPWR _7373_/Q sky130_fd_sc_hd__dfrtp_2
Xhold801 _6893_/Q VGND VGND VPWR VPWR _6893_/D sky130_fd_sc_hd__dlygate4sd3_1
Xhold812 _6903_/Q VGND VGND VPWR VPWR _6903_/D sky130_fd_sc_hd__dlygate4sd3_1
X_4585_ _4585_/A _4589_/B VGND VGND VPWR VPWR _7288_/D sky130_fd_sc_hd__and2_2
X_3605_ _3621_/A _3621_/B VGND VGND VPWR VPWR _3605_/Y sky130_fd_sc_hd__nor2b_2
Xhold823 _6770_/Q VGND VGND VPWR VPWR _6770_/D sky130_fd_sc_hd__dlygate4sd3_1
Xhold834 _6889_/Q VGND VGND VPWR VPWR _6889_/D sky130_fd_sc_hd__dlygate4sd3_1
Xhold845 _7055_/Q VGND VGND VPWR VPWR _7055_/D sky130_fd_sc_hd__dlygate4sd3_1
Xmax_cap553 _5084_/B VGND VGND VPWR VPWR _5085_/A2 sky130_fd_sc_hd__clkdlybuf4s25_1
X_6324_ _6680_/A VGND VGND VPWR VPWR _6324_/Y sky130_fd_sc_hd__inv_2
X_3536_ _4614_/A _3536_/B VGND VGND VPWR VPWR _3536_/Y sky130_fd_sc_hd__nand2_2
XFILLER_107_37 VGND VGND VPWR VPWR sky130_fd_sc_hd__decap_3
Xhold856 _7066_/Q VGND VGND VPWR VPWR _7066_/D sky130_fd_sc_hd__dlygate4sd3_1
Xhold867 _7105_/Q VGND VGND VPWR VPWR _7105_/D sky130_fd_sc_hd__dlygate4sd3_1
Xhold878 _7118_/Q VGND VGND VPWR VPWR _7118_/D sky130_fd_sc_hd__dlygate4sd3_1
Xhold889 _7080_/Q VGND VGND VPWR VPWR _7080_/D sky130_fd_sc_hd__dlygate4sd3_1
XFILLER_103_426 VGND VGND VPWR VPWR sky130_fd_sc_hd__decap_3
XFILLER_88_137 VGND VGND VPWR VPWR sky130_fd_sc_hd__decap_3
X_3467_ _7121_/Q _3407_/X _3409_/X _7153_/Q _3466_/X VGND VGND VPWR VPWR _3467_/X
+ sky130_fd_sc_hd__a221o_2
X_3398_ _4534_/S VGND VGND VPWR VPWR _3398_/Y sky130_fd_sc_hd__inv_2
XFILLER_69_373 VGND VGND VPWR VPWR sky130_fd_sc_hd__decap_3
XFILLER_84_321 VGND VGND VPWR VPWR sky130_fd_sc_hd__decap_3
XFILLER_29_237 VGND VGND VPWR VPWR sky130_fd_sc_hd__decap_3
XFILLER_57_568 VGND VGND VPWR VPWR sky130_fd_sc_hd__decap_3
XFILLER_84_354 VGND VGND VPWR VPWR sky130_fd_sc_hd__decap_3
X_5068_ _6985_/Q _6986_/Q _5068_/C VGND VGND VPWR VPWR _5069_/B sky130_fd_sc_hd__and3_2
XFILLER_72_516 VGND VGND VPWR VPWR sky130_fd_sc_hd__decap_3
XFILLER_84_365 VGND VGND VPWR VPWR sky130_fd_sc_hd__decap_3
X_4019_ _7278_/Q _4422_/A2 _4430_/A2 _7246_/Q _4018_/X VGND VGND VPWR VPWR _4019_/X
+ sky130_fd_sc_hd__a221o_2
XTAP_TAPCELL_ROW_67_1008 VGND VPWR sky130_fd_sc_hd__tapvpwrvgnd_1
XFILLER_37_281 VGND VGND VPWR VPWR sky130_fd_sc_hd__decap_3
XFILLER_52_262 VGND VGND VPWR VPWR sky130_fd_sc_hd__decap_3
XFILLER_80_571 VGND VGND VPWR VPWR sky130_fd_sc_hd__decap_3
XPHY_EDGE_ROW_0_Right_0 VGND VGND VPWR VPWR sky130_fd_sc_hd__decap_3
XFILLER_13_638 VGND VGND VPWR VPWR sky130_fd_sc_hd__decap_3
XFILLER_25_498 VGND VGND VPWR VPWR sky130_fd_sc_hd__decap_3
XFILLER_12_159 VGND VGND VPWR VPWR sky130_fd_sc_hd__decap_3
XFILLER_40_468 VGND VGND VPWR VPWR sky130_fd_sc_hd__fill_2
XFILLER_9_609 VGND VGND VPWR VPWR sky130_fd_sc_hd__decap_3
XFILLER_32_55 VGND VGND VPWR VPWR sky130_fd_sc_hd__decap_3
XFILLER_20_192 VGND VGND VPWR VPWR sky130_fd_sc_hd__decap_3
XTAP_TAPCELL_ROW_78_1126 VGND VPWR sky130_fd_sc_hd__tapvpwrvgnd_1
XTAP_TAPCELL_ROW_10_349 VGND VPWR sky130_fd_sc_hd__tapvpwrvgnd_1
XTAP_TAPCELL_ROW_78_1137 VGND VPWR sky130_fd_sc_hd__tapvpwrvgnd_1
XFILLER_106_242 VGND VGND VPWR VPWR sky130_fd_sc_hd__fill_2
XFILLER_0_542 VGND VGND VPWR VPWR sky130_fd_sc_hd__decap_3
XFILLER_0_564 VGND VGND VPWR VPWR sky130_fd_sc_hd__decap_3
XFILLER_75_310 VGND VGND VPWR VPWR sky130_fd_sc_hd__decap_3
XFILLER_87_181 VGND VGND VPWR VPWR sky130_fd_sc_hd__decap_3
XFILLER_94_118 VGND VGND VPWR VPWR sky130_fd_sc_hd__decap_3
XFILLER_48_557 VGND VGND VPWR VPWR sky130_fd_sc_hd__decap_3
XFILLER_57_63 VGND VGND VPWR VPWR sky130_fd_sc_hd__fill_2
XFILLER_75_343 VGND VGND VPWR VPWR sky130_fd_sc_hd__decap_3
XTAP_TAPCELL_ROW_89_1255 VGND VPWR sky130_fd_sc_hd__tapvpwrvgnd_1
XFILLER_35_218 VGND VGND VPWR VPWR sky130_fd_sc_hd__decap_3
XFILLER_63_505 VGND VGND VPWR VPWR sky130_fd_sc_hd__decap_3
XFILLER_75_387 VGND VGND VPWR VPWR sky130_fd_sc_hd__decap_3
XFILLER_16_421 VGND VGND VPWR VPWR sky130_fd_sc_hd__fill_2
XFILLER_28_270 VGND VGND VPWR VPWR sky130_fd_sc_hd__decap_3
XFILLER_28_292 VGND VGND VPWR VPWR sky130_fd_sc_hd__decap_3
XTAP_TAPCELL_ROW_46_758 VGND VPWR sky130_fd_sc_hd__tapvpwrvgnd_1
XTAP_TAPCELL_ROW_18_438 VGND VPWR sky130_fd_sc_hd__tapvpwrvgnd_1
XFILLER_31_402 VGND VGND VPWR VPWR sky130_fd_sc_hd__fill_1
XFILLER_90_368 VGND VGND VPWR VPWR sky130_fd_sc_hd__decap_3
XTAP_TAPCELL_ROW_46_769 VGND VPWR sky130_fd_sc_hd__tapvpwrvgnd_1
XFILLER_31_424 VGND VGND VPWR VPWR sky130_fd_sc_hd__decap_3
XFILLER_43_284 VGND VGND VPWR VPWR sky130_fd_sc_hd__decap_3
XFILLER_71_582 VGND VGND VPWR VPWR sky130_fd_sc_hd__decap_3
XFILLER_31_457 VGND VGND VPWR VPWR sky130_fd_sc_hd__decap_3
XFILLER_31_479 VGND VGND VPWR VPWR sky130_fd_sc_hd__decap_3
XFILLER_8_631 VGND VGND VPWR VPWR sky130_fd_sc_hd__decap_3
XPHY_EDGE_ROW_91_Left_200 VGND VGND VPWR VPWR sky130_fd_sc_hd__decap_3
XFILLER_11_181 VGND VGND VPWR VPWR sky130_fd_sc_hd__decap_3
XFILLER_7_196 VGND VGND VPWR VPWR sky130_fd_sc_hd__decap_3
X_4370_ _5100_/B _4361_/X _4362_/X _4369_/Y VGND VGND VPWR VPWR _5032_/B sky130_fd_sc_hd__a211o_2
X_3321_ _6981_/Q _3327_/B VGND VGND VPWR VPWR _5294_/A sky130_fd_sc_hd__or2_4
XFILLER_98_413 VGND VGND VPWR VPWR sky130_fd_sc_hd__fill_2
XFILLER_98_446 VGND VGND VPWR VPWR sky130_fd_sc_hd__decap_3
XFILLER_98_424 VGND VGND VPWR VPWR sky130_fd_sc_hd__decap_3
XFILLER_100_429 VGND VGND VPWR VPWR sky130_fd_sc_hd__decap_3
XFILLER_66_321 VGND VGND VPWR VPWR sky130_fd_sc_hd__decap_3
XFILLER_94_630 VGND VGND VPWR VPWR sky130_fd_sc_hd__decap_3
XFILLER_39_557 VGND VGND VPWR VPWR sky130_fd_sc_hd__decap_3
XFILLER_78_192 VGND VGND VPWR VPWR sky130_fd_sc_hd__decap_3
XFILLER_26_218 VGND VGND VPWR VPWR sky130_fd_sc_hd__decap_3
XFILLER_66_365 VGND VGND VPWR VPWR sky130_fd_sc_hd__decap_3
XFILLER_66_376 VGND VGND VPWR VPWR sky130_fd_sc_hd__decap_3
XFILLER_93_184 VGND VGND VPWR VPWR sky130_fd_sc_hd__decap_3
X_6942_ _6968_/CLK _6942_/D VGND VGND VPWR VPWR _6942_/Q sky130_fd_sc_hd__dfxtp_2
X_6873_ _6963_/CLK _6873_/D VGND VGND VPWR VPWR _6873_/Q sky130_fd_sc_hd__dfxtp_2
XFILLER_62_571 VGND VGND VPWR VPWR sky130_fd_sc_hd__decap_3
XFILLER_22_468 VGND VGND VPWR VPWR sky130_fd_sc_hd__decap_3
XFILLER_10_619 VGND VGND VPWR VPWR sky130_fd_sc_hd__decap_3
X_5686_ _7349_/Q hold906/X _5697_/S VGND VGND VPWR VPWR _6693_/D sky130_fd_sc_hd__mux2_2
X_4706_ _6997_/Q _4931_/A VGND VGND VPWR VPWR _4912_/A sky130_fd_sc_hd__and2_2
XFILLER_108_529 VGND VGND VPWR VPWR sky130_fd_sc_hd__decap_3
X_4637_ _4380_/B _4637_/B _4637_/C VGND VGND VPWR VPWR _4950_/B sky130_fd_sc_hd__and3b_2
Xhold620 _6745_/Q VGND VGND VPWR VPWR _6745_/D sky130_fd_sc_hd__dlygate4sd3_1
XFILLER_78_29 VGND VGND VPWR VPWR sky130_fd_sc_hd__fill_2
X_7356_ _7356_/CLK _7356_/D _6636_/Y VGND VGND VPWR VPWR _7356_/Q sky130_fd_sc_hd__dfrtp_2
Xhold631 _6778_/Q VGND VGND VPWR VPWR _6778_/D sky130_fd_sc_hd__dlygate4sd3_1
Xhold642 _6728_/Q VGND VGND VPWR VPWR _6728_/D sky130_fd_sc_hd__dlygate4sd3_1
Xhold653 _6748_/Q VGND VGND VPWR VPWR _6748_/D sky130_fd_sc_hd__dlygate4sd3_1
X_7287_ _7355_/CLK _7287_/D _6567_/Y VGND VGND VPWR VPWR _7287_/Q sky130_fd_sc_hd__dfrtp_2
Xhold664 _6876_/Q VGND VGND VPWR VPWR _6876_/D sky130_fd_sc_hd__dlygate4sd3_1
Xhold675 _6859_/Q VGND VGND VPWR VPWR _6859_/D sky130_fd_sc_hd__dlygate4sd3_1
Xhold686 _6832_/Q VGND VGND VPWR VPWR _6832_/D sky130_fd_sc_hd__dlygate4sd3_1
Xhold697 _6868_/Q VGND VGND VPWR VPWR _6868_/D sky130_fd_sc_hd__dlygate4sd3_1
X_6307_ _6556_/A VGND VGND VPWR VPWR _6307_/Y sky130_fd_sc_hd__inv_2
X_4499_ _4499_/A0 _7298_/Q _4501_/S VGND VGND VPWR VPWR _7330_/D sky130_fd_sc_hd__mux2_2
X_3519_ _5129_/B _3519_/B VGND VGND VPWR VPWR _3519_/Y sky130_fd_sc_hd__nor2_2
XFILLER_103_256 VGND VGND VPWR VPWR sky130_fd_sc_hd__fill_1
XTAP_TAPCELL_ROW_73_1078 VGND VPWR sky130_fd_sc_hd__tapvpwrvgnd_1
XFILLER_103_278 VGND VGND VPWR VPWR sky130_fd_sc_hd__fill_2
XFILLER_76_129 VGND VGND VPWR VPWR sky130_fd_sc_hd__decap_3
XFILLER_85_630 VGND VGND VPWR VPWR sky130_fd_sc_hd__decap_3
XFILLER_17_207 VGND VGND VPWR VPWR sky130_fd_sc_hd__decap_3
XFILLER_27_22 VGND VGND VPWR VPWR sky130_fd_sc_hd__decap_3
XFILLER_45_505 VGND VGND VPWR VPWR sky130_fd_sc_hd__decap_3
XFILLER_72_302 VGND VGND VPWR VPWR sky130_fd_sc_hd__decap_3
XFILLER_27_55 VGND VGND VPWR VPWR sky130_fd_sc_hd__fill_1
XFILLER_72_324 VGND VGND VPWR VPWR sky130_fd_sc_hd__decap_3
XFILLER_84_184 VGND VGND VPWR VPWR sky130_fd_sc_hd__decap_3
XFILLER_25_240 VGND VGND VPWR VPWR sky130_fd_sc_hd__decap_3
XFILLER_25_251 VGND VGND VPWR VPWR sky130_fd_sc_hd__decap_3
XTAP_TAPCELL_ROW_15_408 VGND VPWR sky130_fd_sc_hd__tapvpwrvgnd_1
XFILLER_13_413 VGND VGND VPWR VPWR sky130_fd_sc_hd__decap_3
XFILLER_25_284 VGND VGND VPWR VPWR sky130_fd_sc_hd__decap_3
XTAP_TAPCELL_ROW_43_728 VGND VPWR sky130_fd_sc_hd__tapvpwrvgnd_1
XFILLER_13_446 VGND VGND VPWR VPWR sky130_fd_sc_hd__fill_2
XFILLER_40_221 VGND VGND VPWR VPWR sky130_fd_sc_hd__decap_3
XTAP_TAPCELL_ROW_84_1196 VGND VPWR sky130_fd_sc_hd__tapvpwrvgnd_1
XFILLER_9_417 VGND VGND VPWR VPWR sky130_fd_sc_hd__decap_3
Xclkbuf_leaf_20_clk clkbuf_3_6__f_clk/X VGND VGND VPWR VPWR _7269_/CLK sky130_fd_sc_hd__clkbuf_16
XTAP_TAPCELL_ROW_23_496 VGND VPWR sky130_fd_sc_hd__tapvpwrvgnd_1
XFILLER_5_612 VGND VGND VPWR VPWR sky130_fd_sc_hd__decap_3
XFILLER_5_623 VGND VGND VPWR VPWR sky130_fd_sc_hd__decap_3
XFILLER_108_80 VGND VGND VPWR VPWR sky130_fd_sc_hd__decap_3
XFILLER_108_91 VGND VGND VPWR VPWR sky130_fd_sc_hd__fill_2
XFILLER_0_350 VGND VGND VPWR VPWR sky130_fd_sc_hd__decap_3
XFILLER_95_449 VGND VGND VPWR VPWR sky130_fd_sc_hd__decap_3
XFILLER_48_321 VGND VGND VPWR VPWR sky130_fd_sc_hd__fill_1
XFILLER_48_332 VGND VGND VPWR VPWR sky130_fd_sc_hd__decap_3
XFILLER_76_641 VGND VGND VPWR VPWR sky130_fd_sc_hd__decap_3
XFILLER_48_365 VGND VGND VPWR VPWR sky130_fd_sc_hd__decap_3
XFILLER_29_590 VGND VGND VPWR VPWR sky130_fd_sc_hd__decap_3
XFILLER_48_398 VGND VGND VPWR VPWR sky130_fd_sc_hd__decap_3
XFILLER_63_335 VGND VGND VPWR VPWR sky130_fd_sc_hd__fill_1
Xplace313 _4595_/B VGND VGND VPWR VPWR _4589_/B sky130_fd_sc_hd__buf_2
Xplace302 _3635_/B VGND VGND VPWR VPWR _5033_/B2 sky130_fd_sc_hd__buf_2
XFILLER_44_560 VGND VGND VPWR VPWR sky130_fd_sc_hd__decap_3
XFILLER_51_508 VGND VGND VPWR VPWR sky130_fd_sc_hd__fill_1
XFILLER_63_379 VGND VGND VPWR VPWR sky130_fd_sc_hd__decap_3
XFILLER_90_154 VGND VGND VPWR VPWR sky130_fd_sc_hd__decap_3
Xplace346 _4337_/B VGND VGND VPWR VPWR _4272_/B sky130_fd_sc_hd__buf_2
Xplace335 _4349_/B1 VGND VGND VPWR VPWR _4214_/A2 sky130_fd_sc_hd__buf_2
Xplace324 _4460_/A VGND VGND VPWR VPWR _4205_/A sky130_fd_sc_hd__buf_2
XFILLER_16_262 VGND VGND VPWR VPWR sky130_fd_sc_hd__decap_3
XFILLER_44_582 VGND VGND VPWR VPWR sky130_fd_sc_hd__decap_3
XFILLER_90_187 VGND VGND VPWR VPWR sky130_fd_sc_hd__decap_3
Xplace379 _3874_/A VGND VGND VPWR VPWR _5104_/A sky130_fd_sc_hd__buf_2
Xplace368 _3388_/Y VGND VGND VPWR VPWR _4248_/A sky130_fd_sc_hd__buf_2
Xplace357 _5142_/S VGND VGND VPWR VPWR _5063_/S sky130_fd_sc_hd__buf_2
X_3870_ _6760_/Q _3913_/A2 _3911_/A2 _6754_/Q _3869_/X VGND VGND VPWR VPWR _3870_/X
+ sky130_fd_sc_hd__a221o_2
XFILLER_31_265 VGND VGND VPWR VPWR sky130_fd_sc_hd__decap_3
XFILLER_31_276 VGND VGND VPWR VPWR sky130_fd_sc_hd__decap_3
Xclkbuf_leaf_11_clk clkbuf_leaf_9_clk/A VGND VGND VPWR VPWR _6968_/CLK sky130_fd_sc_hd__clkbuf_16
XFILLER_8_483 VGND VGND VPWR VPWR sky130_fd_sc_hd__decap_3
X_7210_ _7405_/CLK _7210_/D _6490_/Y VGND VGND VPWR VPWR _7210_/Q sky130_fd_sc_hd__dfrtp_2
X_4422_ _7272_/Q _4422_/A2 _4419_/X _4421_/X VGND VGND VPWR VPWR _4422_/X sky130_fd_sc_hd__a211o_2
X_7141_ _7269_/CLK _7141_/D _6421_/Y VGND VGND VPWR VPWR _7141_/Q sky130_fd_sc_hd__dfrtp_2
X_4353_ _7225_/Q _4353_/A2 _4414_/B1 _7193_/Q VGND VGND VPWR VPWR _4355_/A sky130_fd_sc_hd__a22o_2
XFILLER_98_221 VGND VGND VPWR VPWR sky130_fd_sc_hd__decap_3
X_7072_ _7398_/CLK _7072_/D _6352_/Y VGND VGND VPWR VPWR _7072_/Q sky130_fd_sc_hd__dfrtp_2
X_4284_ _7222_/Q _4307_/A2 _3996_/S _7190_/Q VGND VGND VPWR VPWR _4286_/A sky130_fd_sc_hd__a22o_2
X_3304_ _5129_/A _3327_/B VGND VGND VPWR VPWR _4696_/B sky130_fd_sc_hd__nand2_2
XFILLER_98_265 VGND VGND VPWR VPWR sky130_fd_sc_hd__decap_3
XFILLER_98_243 VGND VGND VPWR VPWR sky130_fd_sc_hd__decap_3
XFILLER_100_226 VGND VGND VPWR VPWR sky130_fd_sc_hd__fill_2
XFILLER_86_416 VGND VGND VPWR VPWR sky130_fd_sc_hd__decap_3
XFILLER_104_38 VGND VGND VPWR VPWR sky130_fd_sc_hd__decap_3
XFILLER_27_505 VGND VGND VPWR VPWR sky130_fd_sc_hd__decap_3
XFILLER_39_365 VGND VGND VPWR VPWR sky130_fd_sc_hd__decap_3
XFILLER_82_600 VGND VGND VPWR VPWR sky130_fd_sc_hd__decap_3
XFILLER_66_195 VGND VGND VPWR VPWR sky130_fd_sc_hd__fill_1
XFILLER_42_519 VGND VGND VPWR VPWR sky130_fd_sc_hd__fill_1
XFILLER_54_379 VGND VGND VPWR VPWR sky130_fd_sc_hd__decap_3
XFILLER_81_132 VGND VGND VPWR VPWR sky130_fd_sc_hd__decap_3
XFILLER_81_165 VGND VGND VPWR VPWR sky130_fd_sc_hd__decap_3
X_6925_ clkload5/A _6925_/D VGND VGND VPWR VPWR _6925_/Q sky130_fd_sc_hd__dfxtp_2
XFILLER_81_187 VGND VGND VPWR VPWR sky130_fd_sc_hd__decap_3
XFILLER_22_232 VGND VGND VPWR VPWR sky130_fd_sc_hd__decap_3
XFILLER_50_530 VGND VGND VPWR VPWR sky130_fd_sc_hd__fill_2
Xfanout25 _6630_/A VGND VGND VPWR VPWR _6598_/A sky130_fd_sc_hd__clkdlybuf4s25_1
Xfanout36 _6642_/A VGND VGND VPWR VPWR _6636_/A sky130_fd_sc_hd__buf_2
Xfanout47 fanout48/X VGND VGND VPWR VPWR _6644_/A sky130_fd_sc_hd__clkdlybuf4s25_1
X_6856_ _6943_/CLK _6856_/D VGND VGND VPWR VPWR _6856_/Q sky130_fd_sc_hd__dfxtp_2
XFILLER_10_416 VGND VGND VPWR VPWR sky130_fd_sc_hd__decap_3
Xfanout58 _6616_/A VGND VGND VPWR VPWR _6645_/A sky130_fd_sc_hd__buf_2
Xfanout69 _6278_/A VGND VGND VPWR VPWR _6554_/A sky130_fd_sc_hd__buf_2
X_6787_ _6968_/CLK _6787_/D VGND VGND VPWR VPWR _6787_/Q sky130_fd_sc_hd__dfxtp_2
XFILLER_10_427 VGND VGND VPWR VPWR sky130_fd_sc_hd__decap_3
XFILLER_13_35 VGND VGND VPWR VPWR sky130_fd_sc_hd__decap_3
XFILLER_13_46 VGND VGND VPWR VPWR sky130_fd_sc_hd__decap_3
XFILLER_13_57 VGND VGND VPWR VPWR sky130_fd_sc_hd__fill_2
XFILLER_13_68 VGND VGND VPWR VPWR sky130_fd_sc_hd__decap_3
XTAP_TAPCELL_ROW_20_466 VGND VPWR sky130_fd_sc_hd__tapvpwrvgnd_1
XFILLER_108_337 VGND VGND VPWR VPWR sky130_fd_sc_hd__fill_1
XFILLER_2_604 VGND VGND VPWR VPWR sky130_fd_sc_hd__decap_3
XFILLER_104_510 VGND VGND VPWR VPWR sky130_fd_sc_hd__fill_1
XFILLER_1_125 VGND VGND VPWR VPWR sky130_fd_sc_hd__fill_1
XFILLER_2_637 VGND VGND VPWR VPWR sky130_fd_sc_hd__decap_3
XFILLER_89_210 VGND VGND VPWR VPWR sky130_fd_sc_hd__decap_3
XFILLER_8_6 VGND VGND VPWR VPWR sky130_fd_sc_hd__fill_1
X_7339_ _7363_/CLK _7339_/D _6619_/Y VGND VGND VPWR VPWR _7339_/Q sky130_fd_sc_hd__dfrtp_2
XFILLER_104_598 VGND VGND VPWR VPWR sky130_fd_sc_hd__fill_1
XFILLER_1_169 VGND VGND VPWR VPWR sky130_fd_sc_hd__decap_3
XFILLER_38_32 VGND VGND VPWR VPWR sky130_fd_sc_hd__decap_3
XFILLER_57_140 VGND VGND VPWR VPWR sky130_fd_sc_hd__decap_3
XFILLER_92_419 VGND VGND VPWR VPWR sky130_fd_sc_hd__fill_1
Xhold1150 _7134_/Q VGND VGND VPWR VPWR _5398_/A0 sky130_fd_sc_hd__dlygate4sd3_1
XFILLER_73_633 VGND VGND VPWR VPWR sky130_fd_sc_hd__decap_3
Xhold1161 _7173_/Q VGND VGND VPWR VPWR _5315_/A0 sky130_fd_sc_hd__dlygate4sd3_1
Xhold1172 _7233_/Q VGND VGND VPWR VPWR _5190_/A sky130_fd_sc_hd__dlygate4sd3_1
Xhold1183 _7247_/Q VGND VGND VPWR VPWR _5159_/A0 sky130_fd_sc_hd__dlygate4sd3_1
Xhold1194 _7334_/Q VGND VGND VPWR VPWR _4491_/A0 sky130_fd_sc_hd__dlygate4sd3_1
XTAP_TAPCELL_ROW_86_1225 VGND VPWR sky130_fd_sc_hd__tapvpwrvgnd_1
XFILLER_33_508 VGND VGND VPWR VPWR sky130_fd_sc_hd__decap_3
XTAP_TAPCELL_ROW_56_875 VGND VPWR sky130_fd_sc_hd__tapvpwrvgnd_1
XTAP_TAPCELL_ROW_28_555 VGND VPWR sky130_fd_sc_hd__tapvpwrvgnd_1
XFILLER_60_338 VGND VGND VPWR VPWR sky130_fd_sc_hd__decap_3
XFILLER_72_187 VGND VGND VPWR VPWR sky130_fd_sc_hd__decap_3
XFILLER_13_210 VGND VGND VPWR VPWR sky130_fd_sc_hd__decap_3
XFILLER_26_593 VGND VGND VPWR VPWR sky130_fd_sc_hd__decap_3
XFILLER_41_585 VGND VGND VPWR VPWR sky130_fd_sc_hd__decap_3
XFILLER_9_225 VGND VGND VPWR VPWR sky130_fd_sc_hd__decap_3
XFILLER_70_85 VGND VGND VPWR VPWR sky130_fd_sc_hd__decap_3
Xclkload17 _7280_/CLK VGND VGND VPWR VPWR clkload17/X sky130_fd_sc_hd__clkbuf_1
XFILLER_5_431 VGND VGND VPWR VPWR sky130_fd_sc_hd__decap_3
Xclkload28 _7405_/CLK VGND VGND VPWR VPWR clkload28/Y sky130_fd_sc_hd__clkinv_4
XTAP_TAPCELL_ROW_97_1354 VGND VPWR sky130_fd_sc_hd__tapvpwrvgnd_1
XPHY_EDGE_ROW_10_Left_119 VGND VGND VPWR VPWR sky130_fd_sc_hd__decap_3
XFILLER_68_416 VGND VGND VPWR VPWR sky130_fd_sc_hd__decap_3
XFILLER_95_213 VGND VGND VPWR VPWR sky130_fd_sc_hd__decap_3
XFILLER_0_180 VGND VGND VPWR VPWR sky130_fd_sc_hd__decap_3
XFILLER_49_641 VGND VGND VPWR VPWR sky130_fd_sc_hd__decap_3
XFILLER_95_257 VGND VGND VPWR VPWR sky130_fd_sc_hd__fill_2
Xclkbuf_leaf_0_clk clkbuf_leaf_2_clk/A VGND VGND VPWR VPWR _6958_/CLK sky130_fd_sc_hd__clkbuf_16
XFILLER_95_60 VGND VGND VPWR VPWR sky130_fd_sc_hd__decap_3
XFILLER_36_368 VGND VGND VPWR VPWR sky130_fd_sc_hd__decap_3
XFILLER_91_452 VGND VGND VPWR VPWR sky130_fd_sc_hd__decap_3
XFILLER_17_582 VGND VGND VPWR VPWR sky130_fd_sc_hd__decap_3
XFILLER_51_327 VGND VGND VPWR VPWR sky130_fd_sc_hd__fill_1
XFILLER_91_496 VGND VGND VPWR VPWR sky130_fd_sc_hd__decap_3
X_4971_ _4811_/C _4949_/Y _4967_/X _4969_/X _4970_/X VGND VGND VPWR VPWR _5661_/B
+ sky130_fd_sc_hd__a311oi_2
XTAP_TAPCELL_ROW_106_1450 VGND VPWR sky130_fd_sc_hd__tapvpwrvgnd_1
XFILLER_44_390 VGND VGND VPWR VPWR sky130_fd_sc_hd__decap_3
X_6710_ _7071_/CLK _6710_/D VGND VGND VPWR VPWR _6710_/Q sky130_fd_sc_hd__dfxtp_2
X_3922_ _6778_/Q _3926_/B1 _3925_/B1 _6866_/Q _3921_/X VGND VGND VPWR VPWR _3922_/X
+ sky130_fd_sc_hd__a221o_2
X_6641_ _6642_/A VGND VGND VPWR VPWR _6641_/Y sky130_fd_sc_hd__inv_2
X_3853_ _6736_/Q _3853_/A2 _3887_/A2 _6730_/Q _3852_/X VGND VGND VPWR VPWR _3853_/X
+ sky130_fd_sc_hd__a221o_2
X_6572_ _6601_/A VGND VGND VPWR VPWR _6572_/Y sky130_fd_sc_hd__inv_2
X_3784_ _6847_/Q _3852_/A2 _3852_/B1 _6842_/Q VGND VGND VPWR VPWR _3784_/X sky130_fd_sc_hd__a22o_2
Xoutput511 _5640_/Y VGND VGND VPWR VPWR instruction_out[4] sky130_fd_sc_hd__clkdlybuf4s25_1
Xoutput500 _3417_/C VGND VGND VPWR VPWR instruction_out[21] sky130_fd_sc_hd__clkdlybuf4s25_1
Xoutput544 _3340_/A VGND VGND VPWR VPWR pc_out[5] sky130_fd_sc_hd__clkdlybuf4s25_1
Xoutput533 _7001_/Q VGND VGND VPWR VPWR pc_out[24] sky130_fd_sc_hd__clkdlybuf4s25_1
Xoutput522 _6991_/Q VGND VGND VPWR VPWR pc_out[14] sky130_fd_sc_hd__clkdlybuf4s25_1
X_4405_ _7242_/Q _4433_/B _3945_/S _7210_/Q VGND VGND VPWR VPWR _4405_/X sky130_fd_sc_hd__a22o_2
X_7124_ _7380_/CLK _7124_/D _6404_/Y VGND VGND VPWR VPWR _7124_/Q sky130_fd_sc_hd__dfrtp_2
X_4336_ _4336_/A _4336_/B _4336_/C VGND VGND VPWR VPWR _4336_/X sky130_fd_sc_hd__or3_2
XFILLER_101_502 VGND VGND VPWR VPWR sky130_fd_sc_hd__fill_2
XTAP_TAPCELL_ROW_70_1037 VGND VPWR sky130_fd_sc_hd__tapvpwrvgnd_1
XFILLER_101_535 VGND VGND VPWR VPWR sky130_fd_sc_hd__fill_1
XFILLER_59_449 VGND VGND VPWR VPWR sky130_fd_sc_hd__decap_3
X_7055_ _7380_/CLK _7055_/D _6335_/Y VGND VGND VPWR VPWR _7055_/Q sky130_fd_sc_hd__dfrtp_2
X_4267_ _7134_/Q _4267_/A2 _4352_/B1 _7166_/Q VGND VGND VPWR VPWR _4271_/B sky130_fd_sc_hd__a22o_2
XFILLER_39_140 VGND VGND VPWR VPWR sky130_fd_sc_hd__decap_3
XFILLER_74_419 VGND VGND VPWR VPWR sky130_fd_sc_hd__fill_1
X_4198_ _4194_/X _4197_/X _4327_/A VGND VGND VPWR VPWR _4380_/B sky130_fd_sc_hd__o21ai_2
XFILLER_27_313 VGND VGND VPWR VPWR sky130_fd_sc_hd__decap_3
XFILLER_55_644 VGND VGND VPWR VPWR sky130_fd_sc_hd__decap_3
XFILLER_15_508 VGND VGND VPWR VPWR sky130_fd_sc_hd__decap_3
XFILLER_82_463 VGND VGND VPWR VPWR sky130_fd_sc_hd__decap_3
XFILLER_94_290 VGND VGND VPWR VPWR sky130_fd_sc_hd__decap_3
XFILLER_70_625 VGND VGND VPWR VPWR sky130_fd_sc_hd__decap_3
X_6908_ _6966_/CLK _6908_/D VGND VGND VPWR VPWR _6908_/Q sky130_fd_sc_hd__dfxtp_2
XTAP_TAPCELL_ROW_53_845 VGND VPWR sky130_fd_sc_hd__tapvpwrvgnd_1
XTAP_TAPCELL_ROW_25_525 VGND VPWR sky130_fd_sc_hd__tapvpwrvgnd_1
X_6839_ clkload7/A _6839_/D VGND VGND VPWR VPWR _6839_/Q sky130_fd_sc_hd__dfxtp_2
XTAP_TAPCELL_ROW_81_1166 VGND VPWR sky130_fd_sc_hd__tapvpwrvgnd_1
XFILLER_10_224 VGND VGND VPWR VPWR sky130_fd_sc_hd__decap_3
XFILLER_50_371 VGND VGND VPWR VPWR sky130_fd_sc_hd__decap_3
XFILLER_10_268 VGND VGND VPWR VPWR sky130_fd_sc_hd__decap_3
XFILLER_6_206 VGND VGND VPWR VPWR sky130_fd_sc_hd__decap_3
XFILLER_108_134 VGND VGND VPWR VPWR sky130_fd_sc_hd__decap_3
XFILLER_108_167 VGND VGND VPWR VPWR sky130_fd_sc_hd__fill_1
XFILLER_40_66 VGND VGND VPWR VPWR sky130_fd_sc_hd__fill_1
XFILLER_40_88 VGND VGND VPWR VPWR sky130_fd_sc_hd__decap_3
XFILLER_6_3 VGND VGND VPWR VPWR sky130_fd_sc_hd__decap_3
XFILLER_77_202 VGND VGND VPWR VPWR sky130_fd_sc_hd__decap_3
XTAP_TAPCELL_ROW_92_1295 VGND VPWR sky130_fd_sc_hd__tapvpwrvgnd_1
XFILLER_105_92 VGND VGND VPWR VPWR sky130_fd_sc_hd__decap_3
XFILLER_18_313 VGND VGND VPWR VPWR sky130_fd_sc_hd__fill_2
XFILLER_46_611 VGND VGND VPWR VPWR sky130_fd_sc_hd__decap_3
XFILLER_58_471 VGND VGND VPWR VPWR sky130_fd_sc_hd__decap_3
XFILLER_92_249 VGND VGND VPWR VPWR sky130_fd_sc_hd__decap_3
XTAP_TAPCELL_ROW_5_294 VGND VPWR sky130_fd_sc_hd__tapvpwrvgnd_1
XFILLER_18_368 VGND VGND VPWR VPWR sky130_fd_sc_hd__decap_3
XFILLER_45_154 VGND VGND VPWR VPWR sky130_fd_sc_hd__decap_3
XFILLER_33_316 VGND VGND VPWR VPWR sky130_fd_sc_hd__decap_3
XFILLER_45_176 VGND VGND VPWR VPWR sky130_fd_sc_hd__decap_3
XFILLER_61_647 VGND VGND VPWR VPWR sky130_fd_sc_hd__fill_1
XFILLER_14_574 VGND VGND VPWR VPWR sky130_fd_sc_hd__decap_3
XTAP_TAPCELL_ROW_101_1391 VGND VPWR sky130_fd_sc_hd__tapvpwrvgnd_1
XFILLER_5_272 VGND VGND VPWR VPWR sky130_fd_sc_hd__decap_3
XFILLER_68_224 VGND VGND VPWR VPWR sky130_fd_sc_hd__decap_3
X_4121_ _7140_/Q _4267_/A2 _4436_/B1 _7172_/Q _4120_/X VGND VGND VPWR VPWR _4121_/X
+ sky130_fd_sc_hd__a221o_2
XFILLER_56_419 VGND VGND VPWR VPWR sky130_fd_sc_hd__fill_1
XFILLER_83_205 VGND VGND VPWR VPWR sky130_fd_sc_hd__decap_3
X_4052_ _4047_/X _4050_/X _4425_/A VGND VGND VPWR VPWR _4456_/A sky130_fd_sc_hd__o21a_2
XFILLER_37_644 VGND VGND VPWR VPWR sky130_fd_sc_hd__decap_3
XFILLER_36_165 VGND VGND VPWR VPWR sky130_fd_sc_hd__decap_3
XFILLER_52_636 VGND VGND VPWR VPWR sky130_fd_sc_hd__decap_3
XFILLER_17_390 VGND VGND VPWR VPWR sky130_fd_sc_hd__fill_2
X_4954_ _4950_/A _4969_/C _4953_/Y _4200_/X VGND VGND VPWR VPWR _4954_/X sky130_fd_sc_hd__o211a_2
X_3905_ hold976/X _3423_/A _3904_/Y VGND VGND VPWR VPWR _7380_/D sky130_fd_sc_hd__a21bo_2
XTAP_TAPCELL_ROW_50_815 VGND VPWR sky130_fd_sc_hd__tapvpwrvgnd_1
XTAP_TAPCELL_ROW_50_804 VGND VPWR sky130_fd_sc_hd__tapvpwrvgnd_1
XFILLER_32_371 VGND VGND VPWR VPWR sky130_fd_sc_hd__fill_1
X_4885_ _4904_/B _4903_/A VGND VGND VPWR VPWR _4886_/C sky130_fd_sc_hd__and2b_2
X_6624_ _6624_/A VGND VGND VPWR VPWR _6624_/Y sky130_fd_sc_hd__inv_2
X_3836_ _6970_/Q _3887_/A2 _3887_/B1 _6720_/Q _3835_/X VGND VGND VPWR VPWR _3836_/X
+ sky130_fd_sc_hd__a221o_2
X_6555_ _6556_/A VGND VGND VPWR VPWR _6555_/Y sky130_fd_sc_hd__inv_2
X_3767_ _6705_/Q _3911_/A2 _3912_/B1 _6883_/Q VGND VGND VPWR VPWR _3767_/X sky130_fd_sc_hd__a22o_2
XFILLER_106_616 VGND VGND VPWR VPWR sky130_fd_sc_hd__decap_3
XTAP_TAPCELL_ROW_30_583 VGND VPWR sky130_fd_sc_hd__tapvpwrvgnd_1
XFILLER_105_104 VGND VGND VPWR VPWR sky130_fd_sc_hd__decap_3
X_6486_ _6546_/A VGND VGND VPWR VPWR _6486_/Y sky130_fd_sc_hd__inv_2
X_3698_ _3698_/A1 _4832_/A _3697_/Y VGND VGND VPWR VPWR _7402_/D sky130_fd_sc_hd__o21ba_2
XFILLER_105_148 VGND VGND VPWR VPWR sky130_fd_sc_hd__decap_3
XFILLER_59_246 VGND VGND VPWR VPWR sky130_fd_sc_hd__decap_3
XFILLER_87_555 VGND VGND VPWR VPWR sky130_fd_sc_hd__decap_3
X_7107_ _7366_/CLK _7107_/D _6387_/Y VGND VGND VPWR VPWR _7107_/Q sky130_fd_sc_hd__dfrtp_2
X_4319_ _7258_/Q _4601_/S _4316_/X _4318_/X VGND VGND VPWR VPWR _4362_/A sky130_fd_sc_hd__a211o_2
XFILLER_59_279 VGND VGND VPWR VPWR sky130_fd_sc_hd__fill_1
XFILLER_87_577 VGND VGND VPWR VPWR sky130_fd_sc_hd__fill_2
X_7038_ _7387_/CLK _7038_/D _6318_/Y VGND VGND VPWR VPWR _7038_/Q sky130_fd_sc_hd__dfrtp_2
XTAP_TAPCELL_ROW_58_904 VGND VPWR sky130_fd_sc_hd__tapvpwrvgnd_1
XFILLER_101_376 VGND VGND VPWR VPWR sky130_fd_sc_hd__fill_1
XFILLER_19_89 VGND VGND VPWR VPWR sky130_fd_sc_hd__decap_3
XFILLER_28_622 VGND VGND VPWR VPWR sky130_fd_sc_hd__decap_3
XFILLER_55_441 VGND VGND VPWR VPWR sky130_fd_sc_hd__decap_3
XFILLER_55_452 VGND VGND VPWR VPWR sky130_fd_sc_hd__decap_3
XTAP_TAPCELL_ROW_2_253 VGND VPWR sky130_fd_sc_hd__tapvpwrvgnd_1
XFILLER_27_165 VGND VGND VPWR VPWR sky130_fd_sc_hd__decap_3
XFILLER_43_614 VGND VGND VPWR VPWR sky130_fd_sc_hd__fill_2
XFILLER_55_474 VGND VGND VPWR VPWR sky130_fd_sc_hd__decap_3
XFILLER_82_271 VGND VGND VPWR VPWR sky130_fd_sc_hd__decap_3
XTAP_TAPCELL_ROW_38_672 VGND VPWR sky130_fd_sc_hd__tapvpwrvgnd_1
XFILLER_15_349 VGND VGND VPWR VPWR sky130_fd_sc_hd__decap_3
XFILLER_42_135 VGND VGND VPWR VPWR sky130_fd_sc_hd__decap_3
XFILLER_43_647 VGND VGND VPWR VPWR sky130_fd_sc_hd__fill_1
XTAP_TAPCELL_ROW_66_992 VGND VPWR sky130_fd_sc_hd__tapvpwrvgnd_1
XFILLER_42_157 VGND VGND VPWR VPWR sky130_fd_sc_hd__decap_3
XFILLER_42_179 VGND VGND VPWR VPWR sky130_fd_sc_hd__decap_3
XFILLER_11_555 VGND VGND VPWR VPWR sky130_fd_sc_hd__fill_1
XFILLER_11_588 VGND VGND VPWR VPWR sky130_fd_sc_hd__decap_3
XFILLER_7_537 VGND VGND VPWR VPWR sky130_fd_sc_hd__decap_3
XFILLER_51_98 VGND VGND VPWR VPWR sky130_fd_sc_hd__decap_3
XTAP_TAPCELL_ROW_94_1313 VGND VPWR sky130_fd_sc_hd__tapvpwrvgnd_1
XFILLER_2_220 VGND VGND VPWR VPWR sky130_fd_sc_hd__decap_3
XFILLER_2_242 VGND VGND VPWR VPWR sky130_fd_sc_hd__decap_3
XFILLER_2_253 VGND VGND VPWR VPWR sky130_fd_sc_hd__decap_3
XFILLER_78_500 VGND VGND VPWR VPWR sky130_fd_sc_hd__fill_1
XFILLER_97_308 VGND VGND VPWR VPWR sky130_fd_sc_hd__decap_3
XFILLER_104_192 VGND VGND VPWR VPWR sky130_fd_sc_hd__decap_3
XFILLER_78_533 VGND VGND VPWR VPWR sky130_fd_sc_hd__fill_1
XFILLER_19_600 VGND VGND VPWR VPWR sky130_fd_sc_hd__decap_3
XFILLER_65_205 VGND VGND VPWR VPWR sky130_fd_sc_hd__decap_3
XFILLER_93_525 VGND VGND VPWR VPWR sky130_fd_sc_hd__decap_3
XFILLER_93_547 VGND VGND VPWR VPWR sky130_fd_sc_hd__decap_3
XFILLER_19_644 VGND VGND VPWR VPWR sky130_fd_sc_hd__decap_3
XFILLER_18_165 VGND VGND VPWR VPWR sky130_fd_sc_hd__decap_3
XFILLER_34_614 VGND VGND VPWR VPWR sky130_fd_sc_hd__decap_3
XFILLER_61_411 VGND VGND VPWR VPWR sky130_fd_sc_hd__fill_1
XFILLER_33_113 VGND VGND VPWR VPWR sky130_fd_sc_hd__decap_3
XFILLER_46_496 VGND VGND VPWR VPWR sky130_fd_sc_hd__decap_3
XFILLER_61_444 VGND VGND VPWR VPWR sky130_fd_sc_hd__decap_3
XTAP_TAPCELL_ROW_103_1420 VGND VPWR sky130_fd_sc_hd__tapvpwrvgnd_1
XFILLER_14_393 VGND VGND VPWR VPWR sky130_fd_sc_hd__decap_3
X_4670_ _6995_/Q _5628_/B VGND VGND VPWR VPWR _4682_/B sky130_fd_sc_hd__or2_2
X_3621_ _3621_/A _3621_/B VGND VGND VPWR VPWR _4852_/A sky130_fd_sc_hd__nand2_2
X_6340_ _6463_/A VGND VGND VPWR VPWR _6340_/Y sky130_fd_sc_hd__inv_2
X_3552_ _3508_/Y _5020_/A _3620_/A _3537_/X _3551_/X VGND VGND VPWR VPWR _3746_/A
+ sky130_fd_sc_hd__o311a_2
XFILLER_6_581 VGND VGND VPWR VPWR sky130_fd_sc_hd__decap_3
XFILLER_6_592 VGND VGND VPWR VPWR sky130_fd_sc_hd__decap_3
X_6271_ _6554_/A VGND VGND VPWR VPWR _6271_/Y sky130_fd_sc_hd__inv_2
X_3483_ _3423_/A _3442_/B _3409_/D VGND VGND VPWR VPWR _5153_/B sky130_fd_sc_hd__a21o_2
XFILLER_69_500 VGND VGND VPWR VPWR sky130_fd_sc_hd__decap_3
XPHY_EDGE_ROW_102_Left_211 VGND VGND VPWR VPWR sky130_fd_sc_hd__decap_3
XFILLER_69_522 VGND VGND VPWR VPWR sky130_fd_sc_hd__decap_3
XFILLER_69_533 VGND VGND VPWR VPWR sky130_fd_sc_hd__decap_3
X_5153_ _7010_/D _5153_/B VGND VGND VPWR VPWR _5153_/X sky130_fd_sc_hd__xor2_2
X_4104_ _7237_/Q _4433_/B _4429_/A2 _7050_/Q VGND VGND VPWR VPWR _4104_/X sky130_fd_sc_hd__a22o_2
X_5084_ _4343_/X _5084_/B _5086_/A VGND VGND VPWR VPWR _5084_/X sky130_fd_sc_hd__and3b_2
XFILLER_96_374 VGND VGND VPWR VPWR sky130_fd_sc_hd__fill_2
XFILLER_37_452 VGND VGND VPWR VPWR sky130_fd_sc_hd__fill_1
XFILLER_84_558 VGND VGND VPWR VPWR sky130_fd_sc_hd__decap_3
X_4035_ _7374_/Q _4270_/B _4416_/B1 _7182_/Q _4034_/X VGND VGND VPWR VPWR _4035_/X
+ sky130_fd_sc_hd__a221o_2
XFILLER_25_603 VGND VGND VPWR VPWR sky130_fd_sc_hd__decap_3
XFILLER_37_474 VGND VGND VPWR VPWR sky130_fd_sc_hd__decap_3
XFILLER_71_219 VGND VGND VPWR VPWR sky130_fd_sc_hd__decap_3
XFILLER_24_124 VGND VGND VPWR VPWR sky130_fd_sc_hd__fill_1
XFILLER_25_647 VGND VGND VPWR VPWR sky130_fd_sc_hd__fill_1
XFILLER_52_433 VGND VGND VPWR VPWR sky130_fd_sc_hd__fill_1
XFILLER_92_580 VGND VGND VPWR VPWR sky130_fd_sc_hd__decap_3
XFILLER_24_157 VGND VGND VPWR VPWR sky130_fd_sc_hd__fill_1
XFILLER_24_168 VGND VGND VPWR VPWR sky130_fd_sc_hd__decap_3
XFILLER_52_477 VGND VGND VPWR VPWR sky130_fd_sc_hd__fill_1
XTAP_TAPCELL_ROW_63_962 VGND VPWR sky130_fd_sc_hd__tapvpwrvgnd_1
XTAP_TAPCELL_ROW_35_642 VGND VPWR sky130_fd_sc_hd__tapvpwrvgnd_1
XFILLER_40_639 VGND VGND VPWR VPWR sky130_fd_sc_hd__decap_3
X_4937_ _4937_/A _4937_/B VGND VGND VPWR VPWR _4937_/Y sky130_fd_sc_hd__xnor2_2
XFILLER_32_190 VGND VGND VPWR VPWR sky130_fd_sc_hd__decap_3
X_4868_ _6999_/Q _4882_/A VGND VGND VPWR VPWR _6999_/D sky130_fd_sc_hd__xnor2_2
X_6607_ _6612_/A VGND VGND VPWR VPWR _6607_/Y sky130_fd_sc_hd__inv_2
X_3819_ _6791_/Q _3913_/A2 _3911_/B1 _6879_/Q VGND VGND VPWR VPWR _3819_/X sky130_fd_sc_hd__a22o_2
X_4799_ _4799_/A _5656_/A VGND VGND VPWR VPWR _4799_/X sky130_fd_sc_hd__or2_2
XFILLER_106_402 VGND VGND VPWR VPWR sky130_fd_sc_hd__fill_2
XFILLER_106_424 VGND VGND VPWR VPWR sky130_fd_sc_hd__decap_3
XFILLER_21_57 VGND VGND VPWR VPWR sky130_fd_sc_hd__fill_1
X_6538_ _6636_/A VGND VGND VPWR VPWR _6538_/Y sky130_fd_sc_hd__inv_2
X_6469_ _6667_/A VGND VGND VPWR VPWR _6469_/Y sky130_fd_sc_hd__inv_2
XTAP_TAPCELL_ROW_7_312 VGND VPWR sky130_fd_sc_hd__tapvpwrvgnd_1
XFILLER_102_630 VGND VGND VPWR VPWR sky130_fd_sc_hd__decap_3
XFILLER_101_140 VGND VGND VPWR VPWR sky130_fd_sc_hd__decap_3
XPHY_EDGE_ROW_102_Right_102 VGND VGND VPWR VPWR sky130_fd_sc_hd__decap_3
XFILLER_87_385 VGND VGND VPWR VPWR sky130_fd_sc_hd__decap_3
XFILLER_87_396 VGND VGND VPWR VPWR sky130_fd_sc_hd__decap_3
XFILLER_101_184 VGND VGND VPWR VPWR sky130_fd_sc_hd__fill_2
XFILLER_46_32 VGND VGND VPWR VPWR sky130_fd_sc_hd__decap_3
XFILLER_47_249 VGND VGND VPWR VPWR sky130_fd_sc_hd__decap_3
XFILLER_16_625 VGND VGND VPWR VPWR sky130_fd_sc_hd__decap_3
XFILLER_28_452 VGND VGND VPWR VPWR sky130_fd_sc_hd__decap_3
XFILLER_90_528 VGND VGND VPWR VPWR sky130_fd_sc_hd__decap_3
XFILLER_15_113 VGND VGND VPWR VPWR sky130_fd_sc_hd__fill_2
XFILLER_15_135 VGND VGND VPWR VPWR sky130_fd_sc_hd__decap_3
XFILLER_31_617 VGND VGND VPWR VPWR sky130_fd_sc_hd__decap_3
XFILLER_70_241 VGND VGND VPWR VPWR sky130_fd_sc_hd__decap_3
XFILLER_30_138 VGND VGND VPWR VPWR sky130_fd_sc_hd__fill_2
XFILLER_11_363 VGND VGND VPWR VPWR sky130_fd_sc_hd__decap_3
XFILLER_11_396 VGND VGND VPWR VPWR sky130_fd_sc_hd__decap_3
XFILLER_7_334 VGND VGND VPWR VPWR sky130_fd_sc_hd__fill_2
XFILLER_7_389 VGND VGND VPWR VPWR sky130_fd_sc_hd__decap_3
XFILLER_3_573 VGND VGND VPWR VPWR sky130_fd_sc_hd__decap_3
XFILLER_98_628 VGND VGND VPWR VPWR sky130_fd_sc_hd__decap_3
XFILLER_87_50 VGND VGND VPWR VPWR sky130_fd_sc_hd__decap_3
XFILLER_97_149 VGND VGND VPWR VPWR sky130_fd_sc_hd__decap_3
XFILLER_87_72 VGND VGND VPWR VPWR sky130_fd_sc_hd__decap_3
XFILLER_66_536 VGND VGND VPWR VPWR sky130_fd_sc_hd__decap_3
XFILLER_78_374 VGND VGND VPWR VPWR sky130_fd_sc_hd__decap_3
XFILLER_66_558 VGND VGND VPWR VPWR sky130_fd_sc_hd__decap_3
XFILLER_93_333 VGND VGND VPWR VPWR sky130_fd_sc_hd__decap_3
XFILLER_93_355 VGND VGND VPWR VPWR sky130_fd_sc_hd__decap_3
XFILLER_53_208 VGND VGND VPWR VPWR sky130_fd_sc_hd__decap_3
XFILLER_93_366 VGND VGND VPWR VPWR sky130_fd_sc_hd__decap_3
XFILLER_34_411 VGND VGND VPWR VPWR sky130_fd_sc_hd__decap_3
XFILLER_34_477 VGND VGND VPWR VPWR sky130_fd_sc_hd__decap_3
XFILLER_22_628 VGND VGND VPWR VPWR sky130_fd_sc_hd__decap_3
XTAP_TAPCELL_ROW_60_921 VGND VPWR sky130_fd_sc_hd__tapvpwrvgnd_1
XTAP_TAPCELL_ROW_32_601 VGND VPWR sky130_fd_sc_hd__tapvpwrvgnd_1
XFILLER_14_190 VGND VGND VPWR VPWR sky130_fd_sc_hd__decap_3
X_4653_ _4648_/Y _4785_/A _4413_/A _4397_/A VGND VGND VPWR VPWR _4653_/Y sky130_fd_sc_hd__a211oi_2
X_7372_ _7372_/CLK _7372_/D _6652_/Y VGND VGND VPWR VPWR _7372_/Q sky130_fd_sc_hd__dfrtp_2
Xhold802 _6814_/Q VGND VGND VPWR VPWR _6814_/D sky130_fd_sc_hd__dlygate4sd3_1
X_3604_ _4938_/A _5072_/A VGND VGND VPWR VPWR _3621_/B sky130_fd_sc_hd__nor2_2
Xhold813 _6811_/Q VGND VGND VPWR VPWR _6811_/D sky130_fd_sc_hd__dlygate4sd3_1
Xhold824 _6914_/Q VGND VGND VPWR VPWR _6914_/D sky130_fd_sc_hd__dlygate4sd3_1
Xhold835 _6807_/Q VGND VGND VPWR VPWR _6807_/D sky130_fd_sc_hd__dlygate4sd3_1
Xhold846 _7103_/Q VGND VGND VPWR VPWR _7103_/D sky130_fd_sc_hd__dlygate4sd3_1
Xmax_cap554 _5047_/Y VGND VGND VPWR VPWR _5084_/B sky130_fd_sc_hd__clkdlybuf4s25_1
X_6323_ _6680_/A VGND VGND VPWR VPWR _6323_/Y sky130_fd_sc_hd__inv_2
X_3535_ _3621_/A _5071_/A _3618_/C VGND VGND VPWR VPWR _3536_/B sky130_fd_sc_hd__and3_2
XFILLER_103_405 VGND VGND VPWR VPWR sky130_fd_sc_hd__decap_3
XFILLER_89_617 VGND VGND VPWR VPWR sky130_fd_sc_hd__decap_3
Xhold857 _7056_/Q VGND VGND VPWR VPWR _7056_/D sky130_fd_sc_hd__dlygate4sd3_1
Xhold868 _7117_/Q VGND VGND VPWR VPWR _7117_/D sky130_fd_sc_hd__dlygate4sd3_1
Xhold879 _7110_/Q VGND VGND VPWR VPWR _7110_/D sky130_fd_sc_hd__dlygate4sd3_1
Xmax_cap565 _4467_/Y VGND VGND VPWR VPWR _5581_/S sky130_fd_sc_hd__clkbuf_2
X_3466_ _7217_/Q _4307_/A2 _3488_/B _7030_/Q _3465_/X VGND VGND VPWR VPWR _3466_/X
+ sky130_fd_sc_hd__a221o_2
XFILLER_103_449 VGND VGND VPWR VPWR sky130_fd_sc_hd__decap_3
XFILLER_107_49 VGND VGND VPWR VPWR sky130_fd_sc_hd__decap_3
X_5205_ _5205_/A _5223_/B VGND VGND VPWR VPWR _7226_/D sky130_fd_sc_hd__and2_2
XFILLER_57_503 VGND VGND VPWR VPWR sky130_fd_sc_hd__fill_1
XFILLER_29_205 VGND VGND VPWR VPWR sky130_fd_sc_hd__decap_3
XFILLER_69_396 VGND VGND VPWR VPWR sky130_fd_sc_hd__decap_3
X_5136_ _5136_/A0 _5135_/X _5142_/S VGND VGND VPWR VPWR _7251_/D sky130_fd_sc_hd__mux2_2
XFILLER_29_249 VGND VGND VPWR VPWR sky130_fd_sc_hd__decap_3
XFILLER_57_558 VGND VGND VPWR VPWR sky130_fd_sc_hd__fill_2
XFILLER_84_333 VGND VGND VPWR VPWR sky130_fd_sc_hd__decap_3
X_5067_ _5648_/A _5067_/B VGND VGND VPWR VPWR _5068_/C sky130_fd_sc_hd__or2_2
XFILLER_96_193 VGND VGND VPWR VPWR sky130_fd_sc_hd__decap_3
XFILLER_96_182 VGND VGND VPWR VPWR sky130_fd_sc_hd__decap_3
XFILLER_72_506 VGND VGND VPWR VPWR sky130_fd_sc_hd__decap_3
XFILLER_84_377 VGND VGND VPWR VPWR sky130_fd_sc_hd__decap_3
X_4018_ _7150_/Q _4420_/B1 _4011_/X _4017_/X VGND VGND VPWR VPWR _4018_/X sky130_fd_sc_hd__a211o_2
XTAP_TAPCELL_ROW_67_1009 VGND VPWR sky130_fd_sc_hd__tapvpwrvgnd_1
XFILLER_25_433 VGND VGND VPWR VPWR sky130_fd_sc_hd__decap_3
XFILLER_84_399 VGND VGND VPWR VPWR sky130_fd_sc_hd__decap_3
XFILLER_13_606 VGND VGND VPWR VPWR sky130_fd_sc_hd__decap_3
XFILLER_13_617 VGND VGND VPWR VPWR sky130_fd_sc_hd__decap_3
XFILLER_25_455 VGND VGND VPWR VPWR sky130_fd_sc_hd__decap_3
XFILLER_52_241 VGND VGND VPWR VPWR sky130_fd_sc_hd__decap_3
XFILLER_52_274 VGND VGND VPWR VPWR sky130_fd_sc_hd__decap_3
XFILLER_20_160 VGND VGND VPWR VPWR sky130_fd_sc_hd__fill_2
XFILLER_20_171 VGND VGND VPWR VPWR sky130_fd_sc_hd__decap_3
XTAP_TAPCELL_ROW_78_1127 VGND VPWR sky130_fd_sc_hd__tapvpwrvgnd_1
XFILLER_4_315 VGND VGND VPWR VPWR sky130_fd_sc_hd__decap_3
XFILLER_4_348 VGND VGND VPWR VPWR sky130_fd_sc_hd__decap_3
XFILLER_4_359 VGND VGND VPWR VPWR sky130_fd_sc_hd__decap_3
XFILLER_106_287 VGND VGND VPWR VPWR sky130_fd_sc_hd__decap_3
XFILLER_79_127 VGND VGND VPWR VPWR sky130_fd_sc_hd__decap_3
XFILLER_79_149 VGND VGND VPWR VPWR sky130_fd_sc_hd__decap_3
XFILLER_0_587 VGND VGND VPWR VPWR sky130_fd_sc_hd__fill_1
XFILLER_102_460 VGND VGND VPWR VPWR sky130_fd_sc_hd__decap_3
XFILLER_48_503 VGND VGND VPWR VPWR sky130_fd_sc_hd__decap_3
XFILLER_48_536 VGND VGND VPWR VPWR sky130_fd_sc_hd__decap_3
XFILLER_102_493 VGND VGND VPWR VPWR sky130_fd_sc_hd__decap_3
XFILLER_48_569 VGND VGND VPWR VPWR sky130_fd_sc_hd__decap_3
XFILLER_75_322 VGND VGND VPWR VPWR sky130_fd_sc_hd__decap_3
XFILLER_87_193 VGND VGND VPWR VPWR sky130_fd_sc_hd__fill_1
XTAP_TAPCELL_ROW_89_1256 VGND VPWR sky130_fd_sc_hd__tapvpwrvgnd_1
XFILLER_16_411 VGND VGND VPWR VPWR sky130_fd_sc_hd__decap_3
XFILLER_28_282 VGND VGND VPWR VPWR sky130_fd_sc_hd__decap_3
XFILLER_90_325 VGND VGND VPWR VPWR sky130_fd_sc_hd__decap_3
XFILLER_90_336 VGND VGND VPWR VPWR sky130_fd_sc_hd__decap_3
XTAP_TAPCELL_ROW_46_759 VGND VPWR sky130_fd_sc_hd__tapvpwrvgnd_1
XTAP_TAPCELL_ROW_18_439 VGND VPWR sky130_fd_sc_hd__tapvpwrvgnd_1
XFILLER_43_241 VGND VGND VPWR VPWR sky130_fd_sc_hd__decap_3
XFILLER_71_561 VGND VGND VPWR VPWR sky130_fd_sc_hd__decap_3
XFILLER_73_52 VGND VGND VPWR VPWR sky130_fd_sc_hd__decap_3
XFILLER_73_74 VGND VGND VPWR VPWR sky130_fd_sc_hd__fill_2
XFILLER_16_477 VGND VGND VPWR VPWR sky130_fd_sc_hd__decap_3
XFILLER_8_610 VGND VGND VPWR VPWR sky130_fd_sc_hd__decap_3
XFILLER_8_643 VGND VGND VPWR VPWR sky130_fd_sc_hd__fill_1
XFILLER_11_193 VGND VGND VPWR VPWR sky130_fd_sc_hd__fill_2
XFILLER_7_164 VGND VGND VPWR VPWR sky130_fd_sc_hd__decap_3
XFILLER_7_175 VGND VGND VPWR VPWR sky130_fd_sc_hd__decap_3
X_3320_ _5647_/B VGND VGND VPWR VPWR _5648_/A sky130_fd_sc_hd__inv_2
XFILLER_3_381 VGND VGND VPWR VPWR sky130_fd_sc_hd__decap_3
XFILLER_98_93 VGND VGND VPWR VPWR sky130_fd_sc_hd__decap_3
XFILLER_98_436 VGND VGND VPWR VPWR sky130_fd_sc_hd__fill_2
XFILLER_98_458 VGND VGND VPWR VPWR sky130_fd_sc_hd__decap_3
XFILLER_66_300 VGND VGND VPWR VPWR sky130_fd_sc_hd__decap_3
XFILLER_85_108 VGND VGND VPWR VPWR sky130_fd_sc_hd__decap_3
XFILLER_66_333 VGND VGND VPWR VPWR sky130_fd_sc_hd__decap_3
XFILLER_66_344 VGND VGND VPWR VPWR sky130_fd_sc_hd__decap_3
XFILLER_78_182 VGND VGND VPWR VPWR sky130_fd_sc_hd__decap_3
XFILLER_94_642 VGND VGND VPWR VPWR sky130_fd_sc_hd__fill_2
XFILLER_66_388 VGND VGND VPWR VPWR sky130_fd_sc_hd__fill_1
XFILLER_93_152 VGND VGND VPWR VPWR sky130_fd_sc_hd__decap_3
XFILLER_19_271 VGND VGND VPWR VPWR sky130_fd_sc_hd__decap_3
X_6941_ _6943_/CLK _6941_/D VGND VGND VPWR VPWR _6941_/Q sky130_fd_sc_hd__dfxtp_2
X_6872_ _6958_/CLK _6872_/D VGND VGND VPWR VPWR _6872_/Q sky130_fd_sc_hd__dfxtp_2
XFILLER_22_436 VGND VGND VPWR VPWR sky130_fd_sc_hd__decap_3
XFILLER_34_296 VGND VGND VPWR VPWR sky130_fd_sc_hd__decap_3
XFILLER_30_480 VGND VGND VPWR VPWR sky130_fd_sc_hd__decap_3
XFILLER_30_491 VGND VGND VPWR VPWR sky130_fd_sc_hd__decap_3
X_4705_ _6995_/Q _6996_/Q _4963_/A VGND VGND VPWR VPWR _4931_/A sky130_fd_sc_hd__and3_2
X_4636_ _4186_/A _4636_/B VGND VGND VPWR VPWR _4639_/A sky130_fd_sc_hd__and2b_2
X_7355_ _7355_/CLK _7355_/D _6635_/Y VGND VGND VPWR VPWR _7355_/Q sky130_fd_sc_hd__dfrtp_2
Xhold610 _6812_/Q VGND VGND VPWR VPWR _6812_/D sky130_fd_sc_hd__dlygate4sd3_1
Xhold621 _6906_/Q VGND VGND VPWR VPWR _6906_/D sky130_fd_sc_hd__dlygate4sd3_1
Xhold632 _6793_/Q VGND VGND VPWR VPWR _6793_/D sky130_fd_sc_hd__dlygate4sd3_1
Xhold643 _6925_/Q VGND VGND VPWR VPWR _6925_/D sky130_fd_sc_hd__dlygate4sd3_1
Xhold654 _6833_/Q VGND VGND VPWR VPWR _6833_/D sky130_fd_sc_hd__dlygate4sd3_1
X_6306_ _6556_/A VGND VGND VPWR VPWR _6306_/Y sky130_fd_sc_hd__inv_2
X_4567_ _7297_/Q _4573_/B VGND VGND VPWR VPWR _7297_/D sky130_fd_sc_hd__and2_2
XFILLER_89_447 VGND VGND VPWR VPWR sky130_fd_sc_hd__fill_1
X_7286_ _7348_/CLK _7286_/D _6566_/Y VGND VGND VPWR VPWR _7286_/Q sky130_fd_sc_hd__dfrtp_2
Xhold665 _6899_/Q VGND VGND VPWR VPWR _6899_/D sky130_fd_sc_hd__dlygate4sd3_1
Xhold676 _6878_/Q VGND VGND VPWR VPWR _6878_/D sky130_fd_sc_hd__dlygate4sd3_1
Xhold687 _6857_/Q VGND VGND VPWR VPWR _6857_/D sky130_fd_sc_hd__dlygate4sd3_1
Xhold698 _6936_/Q VGND VGND VPWR VPWR _6936_/D sky130_fd_sc_hd__dlygate4sd3_1
X_3449_ _3449_/A _3449_/B _3449_/C VGND VGND VPWR VPWR _4288_/B sky130_fd_sc_hd__and3_2
XTAP_TAPCELL_ROW_73_1079 VGND VPWR sky130_fd_sc_hd__tapvpwrvgnd_1
XFILLER_57_300 VGND VGND VPWR VPWR sky130_fd_sc_hd__fill_2
XFILLER_85_620 VGND VGND VPWR VPWR sky130_fd_sc_hd__decap_3
XFILLER_69_182 VGND VGND VPWR VPWR sky130_fd_sc_hd__decap_3
X_5119_ _4697_/A _5670_/B _6984_/Q VGND VGND VPWR VPWR _5120_/B sky130_fd_sc_hd__a21oi_2
XFILLER_17_219 VGND VGND VPWR VPWR sky130_fd_sc_hd__decap_3
XFILLER_45_517 VGND VGND VPWR VPWR sky130_fd_sc_hd__decap_3
XFILLER_57_377 VGND VGND VPWR VPWR sky130_fd_sc_hd__fill_1
XFILLER_84_141 VGND VGND VPWR VPWR sky130_fd_sc_hd__decap_3
XFILLER_84_163 VGND VGND VPWR VPWR sky130_fd_sc_hd__decap_3
XFILLER_57_388 VGND VGND VPWR VPWR sky130_fd_sc_hd__decap_3
XFILLER_57_399 VGND VGND VPWR VPWR sky130_fd_sc_hd__decap_3
XFILLER_53_550 VGND VGND VPWR VPWR sky130_fd_sc_hd__fill_2
XFILLER_60_509 VGND VGND VPWR VPWR sky130_fd_sc_hd__decap_3
XFILLER_13_425 VGND VGND VPWR VPWR sky130_fd_sc_hd__decap_3
XFILLER_25_274 VGND VGND VPWR VPWR sky130_fd_sc_hd__decap_3
XFILLER_40_200 VGND VGND VPWR VPWR sky130_fd_sc_hd__decap_3
XFILLER_43_11 VGND VGND VPWR VPWR sky130_fd_sc_hd__fill_1
XFILLER_53_583 VGND VGND VPWR VPWR sky130_fd_sc_hd__decap_3
XTAP_TAPCELL_ROW_43_729 VGND VPWR sky130_fd_sc_hd__tapvpwrvgnd_1
XTAP_TAPCELL_ROW_15_409 VGND VPWR sky130_fd_sc_hd__tapvpwrvgnd_1
XFILLER_25_296 VGND VGND VPWR VPWR sky130_fd_sc_hd__decap_3
XTAP_TAPCELL_ROW_84_1197 VGND VPWR sky130_fd_sc_hd__tapvpwrvgnd_1
XFILLER_43_66 VGND VGND VPWR VPWR sky130_fd_sc_hd__decap_3
XFILLER_21_480 VGND VGND VPWR VPWR sky130_fd_sc_hd__fill_1
XTAP_TAPCELL_ROW_23_497 VGND VPWR sky130_fd_sc_hd__tapvpwrvgnd_1
XFILLER_5_635 VGND VGND VPWR VPWR sky130_fd_sc_hd__decap_3
XFILLER_4_189 VGND VGND VPWR VPWR sky130_fd_sc_hd__decap_3
XFILLER_68_41 VGND VGND VPWR VPWR sky130_fd_sc_hd__fill_2
XFILLER_67_108 VGND VGND VPWR VPWR sky130_fd_sc_hd__decap_3
XFILLER_68_85 VGND VGND VPWR VPWR sky130_fd_sc_hd__decap_3
XFILLER_95_417 VGND VGND VPWR VPWR sky130_fd_sc_hd__decap_3
XFILLER_102_290 VGND VGND VPWR VPWR sky130_fd_sc_hd__decap_3
XFILLER_48_344 VGND VGND VPWR VPWR sky130_fd_sc_hd__decap_3
XFILLER_88_491 VGND VGND VPWR VPWR sky130_fd_sc_hd__fill_2
XFILLER_36_506 VGND VGND VPWR VPWR sky130_fd_sc_hd__decap_3
XFILLER_48_355 VGND VGND VPWR VPWR sky130_fd_sc_hd__decap_3
XFILLER_36_539 VGND VGND VPWR VPWR sky130_fd_sc_hd__decap_3
XFILLER_63_314 VGND VGND VPWR VPWR sky130_fd_sc_hd__decap_3
XFILLER_75_196 VGND VGND VPWR VPWR sky130_fd_sc_hd__decap_3
XFILLER_91_645 VGND VGND VPWR VPWR sky130_fd_sc_hd__decap_3
Xplace303 _5146_/B1 VGND VGND VPWR VPWR _4811_/C sky130_fd_sc_hd__buf_2
XFILLER_44_550 VGND VGND VPWR VPWR sky130_fd_sc_hd__decap_3
Xplace336 _3377_/X VGND VGND VPWR VPWR _4349_/B1 sky130_fd_sc_hd__buf_2
Xplace325 _3429_/X VGND VGND VPWR VPWR _4460_/A sky130_fd_sc_hd__buf_2
Xplace314 _5292_/S VGND VGND VPWR VPWR _5276_/S sky130_fd_sc_hd__buf_2
XFILLER_31_200 VGND VGND VPWR VPWR sky130_fd_sc_hd__decap_3
XFILLER_90_166 VGND VGND VPWR VPWR sky130_fd_sc_hd__decap_3
Xplace369 _3509_/B VGND VGND VPWR VPWR _4791_/C1 sky130_fd_sc_hd__buf_2
Xplace358 _5132_/S VGND VGND VPWR VPWR _5142_/S sky130_fd_sc_hd__buf_2
Xplace347 _4337_/B VGND VGND VPWR VPWR _4270_/B sky130_fd_sc_hd__buf_2
XFILLER_31_222 VGND VGND VPWR VPWR sky130_fd_sc_hd__fill_2
XFILLER_71_380 VGND VGND VPWR VPWR sky130_fd_sc_hd__decap_3
XFILLER_90_6 VGND VGND VPWR VPWR sky130_fd_sc_hd__fill_1
XFILLER_12_480 VGND VGND VPWR VPWR sky130_fd_sc_hd__fill_1
XFILLER_8_451 VGND VGND VPWR VPWR sky130_fd_sc_hd__fill_2
XFILLER_8_473 VGND VGND VPWR VPWR sky130_fd_sc_hd__decap_3
XFILLER_69_3 VGND VGND VPWR VPWR sky130_fd_sc_hd__decap_3
X_4421_ _7240_/Q _4430_/A2 _4459_/C1 _7176_/Q _4420_/X VGND VGND VPWR VPWR _4421_/X
+ sky130_fd_sc_hd__a221o_2
X_7140_ _7361_/CLK _7140_/D _6420_/Y VGND VGND VPWR VPWR _7140_/Q sky130_fd_sc_hd__dfrtp_2
X_4352_ _7289_/Q _4352_/A2 _4352_/B1 _7161_/Q _4351_/X VGND VGND VPWR VPWR _4352_/X
+ sky130_fd_sc_hd__a221o_2
XFILLER_98_200 VGND VGND VPWR VPWR sky130_fd_sc_hd__decap_3
XFILLER_59_609 VGND VGND VPWR VPWR sky130_fd_sc_hd__decap_3
X_7071_ _7071_/CLK _7071_/D _6351_/Y VGND VGND VPWR VPWR _7071_/Q sky130_fd_sc_hd__dfrtp_2
X_4283_ _7094_/Q _4335_/B1 _3407_/X _7126_/Q VGND VGND VPWR VPWR _4283_/X sky130_fd_sc_hd__a22o_2
X_3303_ _4467_/A _3519_/B _3302_/X VGND VGND VPWR VPWR _6981_/D sky130_fd_sc_hd__o21a_4
XFILLER_98_233 VGND VGND VPWR VPWR sky130_fd_sc_hd__decap_3
XFILLER_86_439 VGND VGND VPWR VPWR sky130_fd_sc_hd__fill_2
XFILLER_98_277 VGND VGND VPWR VPWR sky130_fd_sc_hd__decap_3
XFILLER_100_249 VGND VGND VPWR VPWR sky130_fd_sc_hd__decap_3
XFILLER_104_17 VGND VGND VPWR VPWR sky130_fd_sc_hd__decap_3
XFILLER_67_631 VGND VGND VPWR VPWR sky130_fd_sc_hd__decap_3
XFILLER_39_377 VGND VGND VPWR VPWR sky130_fd_sc_hd__fill_1
XFILLER_54_303 VGND VGND VPWR VPWR sky130_fd_sc_hd__decap_3
XFILLER_66_141 VGND VGND VPWR VPWR sky130_fd_sc_hd__decap_3
XFILLER_66_163 VGND VGND VPWR VPWR sky130_fd_sc_hd__decap_3
XFILLER_27_539 VGND VGND VPWR VPWR sky130_fd_sc_hd__decap_3
XFILLER_39_388 VGND VGND VPWR VPWR sky130_fd_sc_hd__decap_3
XFILLER_39_399 VGND VGND VPWR VPWR sky130_fd_sc_hd__decap_3
XFILLER_66_174 VGND VGND VPWR VPWR sky130_fd_sc_hd__fill_2
XFILLER_81_111 VGND VGND VPWR VPWR sky130_fd_sc_hd__fill_1
XFILLER_81_122 VGND VGND VPWR VPWR sky130_fd_sc_hd__fill_2
XFILLER_82_634 VGND VGND VPWR VPWR sky130_fd_sc_hd__fill_1
XFILLER_82_645 VGND VGND VPWR VPWR sky130_fd_sc_hd__decap_3
XFILLER_81_144 VGND VGND VPWR VPWR sky130_fd_sc_hd__decap_3
X_6924_ clkload9/A _6924_/D VGND VGND VPWR VPWR _6924_/Q sky130_fd_sc_hd__dfxtp_2
XFILLER_22_200 VGND VGND VPWR VPWR sky130_fd_sc_hd__fill_1
XFILLER_35_561 VGND VGND VPWR VPWR sky130_fd_sc_hd__decap_3
XFILLER_22_211 VGND VGND VPWR VPWR sky130_fd_sc_hd__decap_3
XFILLER_50_520 VGND VGND VPWR VPWR sky130_fd_sc_hd__decap_3
XFILLER_81_199 VGND VGND VPWR VPWR sky130_fd_sc_hd__decap_3
Xfanout26 _6559_/A VGND VGND VPWR VPWR _6630_/A sky130_fd_sc_hd__buf_2
Xfanout37 _6637_/A VGND VGND VPWR VPWR _6536_/A sky130_fd_sc_hd__clkbuf_2
X_6855_ _6976_/CLK _6855_/D VGND VGND VPWR VPWR _6855_/Q sky130_fd_sc_hd__dfxtp_2
XFILLER_13_14 VGND VGND VPWR VPWR sky130_fd_sc_hd__fill_2
XFILLER_22_244 VGND VGND VPWR VPWR sky130_fd_sc_hd__fill_1
XFILLER_22_277 VGND VGND VPWR VPWR sky130_fd_sc_hd__decap_3
Xfanout48 reset VGND VGND VPWR VPWR fanout48/X sky130_fd_sc_hd__clkdlybuf4s25_1
Xfanout59 _6616_/A VGND VGND VPWR VPWR _6648_/A sky130_fd_sc_hd__buf_1
X_6786_ clkload9/A _6786_/D VGND VGND VPWR VPWR _6786_/Q sky130_fd_sc_hd__dfxtp_2
XFILLER_22_299 VGND VGND VPWR VPWR sky130_fd_sc_hd__decap_3
X_5737_ _7374_/Q hold905/X _5737_/S VGND VGND VPWR VPWR _6718_/D sky130_fd_sc_hd__mux2_2
XFILLER_108_349 VGND VGND VPWR VPWR sky130_fd_sc_hd__decap_3
X_5668_ _5668_/A _5668_/B VGND VGND VPWR VPWR _6980_/D sky130_fd_sc_hd__or2_2
XTAP_TAPCELL_ROW_20_467 VGND VPWR sky130_fd_sc_hd__tapvpwrvgnd_1
X_4619_ _5086_/A _4619_/B _5101_/B _5073_/A VGND VGND VPWR VPWR _4619_/Y sky130_fd_sc_hd__nor4_2
XFILLER_2_616 VGND VGND VPWR VPWR sky130_fd_sc_hd__decap_3
X_7338_ _7374_/CLK _7338_/D _6618_/Y VGND VGND VPWR VPWR _7338_/Q sky130_fd_sc_hd__dfrtp_2
XFILLER_104_533 VGND VGND VPWR VPWR sky130_fd_sc_hd__decap_3
X_7269_ _7269_/CLK _7269_/D _6549_/Y VGND VGND VPWR VPWR _7269_/Q sky130_fd_sc_hd__dfrtp_2
XFILLER_104_577 VGND VGND VPWR VPWR sky130_fd_sc_hd__decap_3
XFILLER_58_631 VGND VGND VPWR VPWR sky130_fd_sc_hd__decap_3
XFILLER_18_506 VGND VGND VPWR VPWR sky130_fd_sc_hd__decap_3
XFILLER_38_55 VGND VGND VPWR VPWR sky130_fd_sc_hd__decap_3
XFILLER_38_88 VGND VGND VPWR VPWR sky130_fd_sc_hd__fill_1
XFILLER_73_601 VGND VGND VPWR VPWR sky130_fd_sc_hd__decap_3
XFILLER_85_461 VGND VGND VPWR VPWR sky130_fd_sc_hd__fill_1
Xhold1140 _7217_/Q VGND VGND VPWR VPWR _5223_/A sky130_fd_sc_hd__dlygate4sd3_1
Xhold1151 _7314_/Q VGND VGND VPWR VPWR _4530_/A0 sky130_fd_sc_hd__dlygate4sd3_1
XFILLER_73_645 VGND VGND VPWR VPWR sky130_fd_sc_hd__decap_3
XFILLER_85_483 VGND VGND VPWR VPWR sky130_fd_sc_hd__decap_3
Xhold1162 _7131_/Q VGND VGND VPWR VPWR _5404_/A0 sky130_fd_sc_hd__dlygate4sd3_1
Xhold1173 _7180_/Q VGND VGND VPWR VPWR _5300_/A0 sky130_fd_sc_hd__dlygate4sd3_1
Xhold1184 _7396_/Q VGND VGND VPWR VPWR _3757_/A0 sky130_fd_sc_hd__dlygate4sd3_1
XTAP_TAPCELL_ROW_86_1226 VGND VPWR sky130_fd_sc_hd__tapvpwrvgnd_1
XFILLER_54_32 VGND VGND VPWR VPWR sky130_fd_sc_hd__decap_3
XFILLER_72_144 VGND VGND VPWR VPWR sky130_fd_sc_hd__fill_2
Xhold1195 _7148_/Q VGND VGND VPWR VPWR _5369_/A0 sky130_fd_sc_hd__dlygate4sd3_1
XTAP_TAPCELL_ROW_28_556 VGND VPWR sky130_fd_sc_hd__tapvpwrvgnd_1
XFILLER_60_317 VGND VGND VPWR VPWR sky130_fd_sc_hd__decap_3
XTAP_TAPCELL_ROW_56_876 VGND VPWR sky130_fd_sc_hd__tapvpwrvgnd_1
XFILLER_13_222 VGND VGND VPWR VPWR sky130_fd_sc_hd__fill_2
XFILLER_13_255 VGND VGND VPWR VPWR sky130_fd_sc_hd__fill_1
XFILLER_13_277 VGND VGND VPWR VPWR sky130_fd_sc_hd__decap_3
XFILLER_9_259 VGND VGND VPWR VPWR sky130_fd_sc_hd__decap_3
XFILLER_5_410 VGND VGND VPWR VPWR sky130_fd_sc_hd__fill_1
Xclkload18 _7352_/CLK VGND VGND VPWR VPWR clkload18/X sky130_fd_sc_hd__clkbuf_1
Xclkload29 _7406_/CLK VGND VGND VPWR VPWR clkload29/Y sky130_fd_sc_hd__clkinv_4
XTAP_TAPCELL_ROW_97_1355 VGND VPWR sky130_fd_sc_hd__tapvpwrvgnd_1
XFILLER_107_393 VGND VGND VPWR VPWR sky130_fd_sc_hd__decap_3
XFILLER_49_620 VGND VGND VPWR VPWR sky130_fd_sc_hd__decap_3
XFILLER_95_225 VGND VGND VPWR VPWR sky130_fd_sc_hd__decap_3
XFILLER_48_141 VGND VGND VPWR VPWR sky130_fd_sc_hd__decap_3
XFILLER_76_450 VGND VGND VPWR VPWR sky130_fd_sc_hd__decap_3
XFILLER_36_325 VGND VGND VPWR VPWR sky130_fd_sc_hd__fill_1
XFILLER_63_111 VGND VGND VPWR VPWR sky130_fd_sc_hd__fill_1
XFILLER_64_623 VGND VGND VPWR VPWR sky130_fd_sc_hd__decap_3
XFILLER_64_645 VGND VGND VPWR VPWR sky130_fd_sc_hd__decap_3
XFILLER_91_431 VGND VGND VPWR VPWR sky130_fd_sc_hd__decap_3
XFILLER_91_464 VGND VGND VPWR VPWR sky130_fd_sc_hd__decap_3
XFILLER_63_166 VGND VGND VPWR VPWR sky130_fd_sc_hd__fill_2
XFILLER_63_188 VGND VGND VPWR VPWR sky130_fd_sc_hd__decap_3
X_4970_ _5006_/A1 _4950_/B _4967_/B _5033_/B2 VGND VGND VPWR VPWR _4970_/X sky130_fd_sc_hd__a22o_2
XTAP_TAPCELL_ROW_106_1451 VGND VPWR sky130_fd_sc_hd__tapvpwrvgnd_1
XFILLER_17_594 VGND VGND VPWR VPWR sky130_fd_sc_hd__decap_3
X_3921_ _6914_/Q _3926_/A2 _5660_/B _6688_/Q VGND VGND VPWR VPWR _3921_/X sky130_fd_sc_hd__a22o_2
X_6640_ _6640_/A VGND VGND VPWR VPWR _6640_/Y sky130_fd_sc_hd__inv_2
X_3852_ _6748_/Q _3852_/A2 _3852_/B1 _6742_/Q VGND VGND VPWR VPWR _3852_/X sky130_fd_sc_hd__a22o_2
XFILLER_32_586 VGND VGND VPWR VPWR sky130_fd_sc_hd__fill_2
X_6571_ _6603_/A VGND VGND VPWR VPWR _6571_/Y sky130_fd_sc_hd__inv_2
X_3783_ _6812_/Q _3656_/Y _3887_/B1 _6822_/Q _3782_/X VGND VGND VPWR VPWR _3783_/X
+ sky130_fd_sc_hd__a221o_2
XFILLER_8_281 VGND VGND VPWR VPWR sky130_fd_sc_hd__decap_3
XFILLER_105_308 VGND VGND VPWR VPWR sky130_fd_sc_hd__decap_3
Xoutput501 _3449_/A VGND VGND VPWR VPWR instruction_out[22] sky130_fd_sc_hd__clkdlybuf4s25_1
Xoutput545 _4697_/A VGND VGND VPWR VPWR pc_out[6] sky130_fd_sc_hd__clkdlybuf4s25_1
Xoutput534 _7002_/Q VGND VGND VPWR VPWR pc_out[25] sky130_fd_sc_hd__clkdlybuf4s25_1
Xoutput523 _6992_/Q VGND VGND VPWR VPWR pc_out[15] sky130_fd_sc_hd__clkdlybuf4s25_1
Xoutput512 _5643_/X VGND VGND VPWR VPWR instruction_out[5] sky130_fd_sc_hd__clkdlybuf4s25_1
X_4404_ _7306_/Q _4865_/S _4434_/A2 _7114_/Q VGND VGND VPWR VPWR _4404_/X sky130_fd_sc_hd__a22o_2
X_7123_ _7349_/CLK _7123_/D _6403_/Y VGND VGND VPWR VPWR _7123_/Q sky130_fd_sc_hd__dfrtp_2
X_4335_ _7287_/Q _5063_/S _4335_/B1 _7095_/Q VGND VGND VPWR VPWR _4336_/C sky130_fd_sc_hd__a22o_2
XFILLER_99_542 VGND VGND VPWR VPWR sky130_fd_sc_hd__decap_3
XFILLER_101_514 VGND VGND VPWR VPWR sky130_fd_sc_hd__decap_3
XTAP_TAPCELL_ROW_70_1038 VGND VPWR sky130_fd_sc_hd__tapvpwrvgnd_1
XFILLER_101_547 VGND VGND VPWR VPWR sky130_fd_sc_hd__decap_3
X_7054_ _7372_/CLK _7054_/D _6334_/Y VGND VGND VPWR VPWR _7054_/Q sky130_fd_sc_hd__dfrtp_2
X_4266_ _7294_/Q _5063_/S _4335_/B1 _7102_/Q VGND VGND VPWR VPWR _4271_/A sky130_fd_sc_hd__a22o_2
XFILLER_39_152 VGND VGND VPWR VPWR sky130_fd_sc_hd__decap_3
XFILLER_67_461 VGND VGND VPWR VPWR sky130_fd_sc_hd__decap_3
X_4197_ _7199_/Q _4414_/B1 _4244_/B _7044_/Q _4196_/X VGND VGND VPWR VPWR _4197_/X
+ sky130_fd_sc_hd__a221o_2
XFILLER_55_623 VGND VGND VPWR VPWR sky130_fd_sc_hd__decap_3
XFILLER_39_196 VGND VGND VPWR VPWR sky130_fd_sc_hd__decap_3
XFILLER_70_637 VGND VGND VPWR VPWR sky130_fd_sc_hd__decap_3
XFILLER_82_475 VGND VGND VPWR VPWR sky130_fd_sc_hd__fill_1
XFILLER_82_486 VGND VGND VPWR VPWR sky130_fd_sc_hd__decap_3
XFILLER_23_531 VGND VGND VPWR VPWR sky130_fd_sc_hd__decap_3
XFILLER_35_391 VGND VGND VPWR VPWR sky130_fd_sc_hd__fill_1
X_6907_ clkload3/A _6907_/D VGND VGND VPWR VPWR _6907_/Q sky130_fd_sc_hd__dfxtp_2
XTAP_TAPCELL_ROW_53_846 VGND VPWR sky130_fd_sc_hd__tapvpwrvgnd_1
XTAP_TAPCELL_ROW_25_526 VGND VPWR sky130_fd_sc_hd__tapvpwrvgnd_1
XFILLER_23_564 VGND VGND VPWR VPWR sky130_fd_sc_hd__decap_3
X_6838_ _6958_/CLK _6838_/D VGND VGND VPWR VPWR _6838_/Q sky130_fd_sc_hd__dfxtp_2
XTAP_TAPCELL_ROW_81_1167 VGND VPWR sky130_fd_sc_hd__tapvpwrvgnd_1
XFILLER_10_203 VGND VGND VPWR VPWR sky130_fd_sc_hd__decap_3
XFILLER_10_236 VGND VGND VPWR VPWR sky130_fd_sc_hd__fill_2
XFILLER_10_247 VGND VGND VPWR VPWR sky130_fd_sc_hd__decap_3
X_6769_ _6966_/CLK _6769_/D VGND VGND VPWR VPWR _6769_/Q sky130_fd_sc_hd__dfxtp_2
XFILLER_108_113 VGND VGND VPWR VPWR sky130_fd_sc_hd__decap_3
XFILLER_6_218 VGND VGND VPWR VPWR sky130_fd_sc_hd__fill_1
XFILLER_6_229 VGND VGND VPWR VPWR sky130_fd_sc_hd__fill_2
XFILLER_2_413 VGND VGND VPWR VPWR sky130_fd_sc_hd__decap_3
XFILLER_104_374 VGND VGND VPWR VPWR sky130_fd_sc_hd__decap_3
XFILLER_77_214 VGND VGND VPWR VPWR sky130_fd_sc_hd__decap_3
XTAP_TAPCELL_ROW_92_1296 VGND VPWR sky130_fd_sc_hd__tapvpwrvgnd_1
XFILLER_77_225 VGND VGND VPWR VPWR sky130_fd_sc_hd__decap_3
XFILLER_77_258 VGND VGND VPWR VPWR sky130_fd_sc_hd__decap_3
XFILLER_92_206 VGND VGND VPWR VPWR sky130_fd_sc_hd__decap_3
XFILLER_100_580 VGND VGND VPWR VPWR sky130_fd_sc_hd__decap_3
XFILLER_18_303 VGND VGND VPWR VPWR sky130_fd_sc_hd__decap_3
XFILLER_46_623 VGND VGND VPWR VPWR sky130_fd_sc_hd__decap_3
XFILLER_58_483 VGND VGND VPWR VPWR sky130_fd_sc_hd__fill_1
XFILLER_73_420 VGND VGND VPWR VPWR sky130_fd_sc_hd__decap_3
XFILLER_92_228 VGND VGND VPWR VPWR sky130_fd_sc_hd__decap_3
XTAP_TAPCELL_ROW_5_295 VGND VPWR sky130_fd_sc_hd__tapvpwrvgnd_1
XFILLER_45_122 VGND VGND VPWR VPWR sky130_fd_sc_hd__decap_3
XFILLER_46_645 VGND VGND VPWR VPWR sky130_fd_sc_hd__decap_3
XFILLER_65_75 VGND VGND VPWR VPWR sky130_fd_sc_hd__fill_1
XFILLER_85_291 VGND VGND VPWR VPWR sky130_fd_sc_hd__decap_3
XFILLER_45_166 VGND VGND VPWR VPWR sky130_fd_sc_hd__fill_2
XFILLER_61_615 VGND VGND VPWR VPWR sky130_fd_sc_hd__fill_1
XFILLER_61_626 VGND VGND VPWR VPWR sky130_fd_sc_hd__decap_3
XFILLER_14_520 VGND VGND VPWR VPWR sky130_fd_sc_hd__fill_2
XFILLER_14_531 VGND VGND VPWR VPWR sky130_fd_sc_hd__fill_1
XFILLER_45_188 VGND VGND VPWR VPWR sky130_fd_sc_hd__decap_3
XFILLER_14_586 VGND VGND VPWR VPWR sky130_fd_sc_hd__fill_2
XTAP_TAPCELL_ROW_101_1392 VGND VPWR sky130_fd_sc_hd__tapvpwrvgnd_1
XFILLER_5_251 VGND VGND VPWR VPWR sky130_fd_sc_hd__decap_3
XFILLER_5_284 VGND VGND VPWR VPWR sky130_fd_sc_hd__decap_3
XFILLER_5_295 VGND VGND VPWR VPWR sky130_fd_sc_hd__decap_3
XFILLER_68_203 VGND VGND VPWR VPWR sky130_fd_sc_hd__decap_3
XFILLER_68_236 VGND VGND VPWR VPWR sky130_fd_sc_hd__fill_1
XFILLER_68_247 VGND VGND VPWR VPWR sky130_fd_sc_hd__decap_3
X_4120_ _7300_/Q _4352_/A2 _4351_/A2 _7108_/Q VGND VGND VPWR VPWR _4120_/X sky130_fd_sc_hd__a22o_2
XFILLER_96_545 VGND VGND VPWR VPWR sky130_fd_sc_hd__decap_3
XFILLER_37_601 VGND VGND VPWR VPWR sky130_fd_sc_hd__decap_3
XFILLER_96_589 VGND VGND VPWR VPWR sky130_fd_sc_hd__decap_3
XFILLER_37_623 VGND VGND VPWR VPWR sky130_fd_sc_hd__decap_3
XFILLER_49_461 VGND VGND VPWR VPWR sky130_fd_sc_hd__decap_3
XFILLER_83_217 VGND VGND VPWR VPWR sky130_fd_sc_hd__decap_3
XFILLER_83_228 VGND VGND VPWR VPWR sky130_fd_sc_hd__decap_3
XFILLER_36_133 VGND VGND VPWR VPWR sky130_fd_sc_hd__decap_3
XFILLER_36_144 VGND VGND VPWR VPWR sky130_fd_sc_hd__decap_3
XFILLER_36_177 VGND VGND VPWR VPWR sky130_fd_sc_hd__decap_3
XFILLER_52_615 VGND VGND VPWR VPWR sky130_fd_sc_hd__decap_3
XFILLER_64_475 VGND VGND VPWR VPWR sky130_fd_sc_hd__fill_1
XFILLER_101_18 VGND VGND VPWR VPWR sky130_fd_sc_hd__decap_3
XFILLER_51_125 VGND VGND VPWR VPWR sky130_fd_sc_hd__fill_1
XFILLER_51_136 VGND VGND VPWR VPWR sky130_fd_sc_hd__decap_3
XFILLER_91_294 VGND VGND VPWR VPWR sky130_fd_sc_hd__decap_3
X_4953_ _4950_/A _4381_/A _4969_/C _4814_/A VGND VGND VPWR VPWR _4953_/Y sky130_fd_sc_hd__a31oi_2
XFILLER_51_158 VGND VGND VPWR VPWR sky130_fd_sc_hd__decap_3
XFILLER_51_169 VGND VGND VPWR VPWR sky130_fd_sc_hd__decap_3
X_3904_ _5151_/A _3904_/B VGND VGND VPWR VPWR _3904_/Y sky130_fd_sc_hd__nand2_2
XTAP_TAPCELL_ROW_50_805 VGND VPWR sky130_fd_sc_hd__tapvpwrvgnd_1
X_6623_ _6662_/A VGND VGND VPWR VPWR _6623_/Y sky130_fd_sc_hd__inv_2
X_4884_ _4884_/A _4904_/B VGND VGND VPWR VPWR _4884_/X sky130_fd_sc_hd__or2_2
X_3835_ _6725_/Q _3886_/A2 _3886_/B1 _6975_/Q VGND VGND VPWR VPWR _3835_/X sky130_fd_sc_hd__a22o_2
XFILLER_20_589 VGND VGND VPWR VPWR sky130_fd_sc_hd__decap_3
X_6554_ _6554_/A VGND VGND VPWR VPWR _6554_/Y sky130_fd_sc_hd__inv_2
X_3766_ hold959/X _3857_/A2 _4927_/B VGND VGND VPWR VPWR _7394_/D sky130_fd_sc_hd__a21o_2
X_6485_ _6485_/A VGND VGND VPWR VPWR _6485_/Y sky130_fd_sc_hd__inv_2
XTAP_TAPCELL_ROW_30_584 VGND VPWR sky130_fd_sc_hd__tapvpwrvgnd_1
XFILLER_106_628 VGND VGND VPWR VPWR sky130_fd_sc_hd__decap_3
X_3697_ _3682_/A _3696_/X _5104_/A VGND VGND VPWR VPWR _3697_/Y sky130_fd_sc_hd__a21oi_2
XFILLER_105_127 VGND VGND VPWR VPWR sky130_fd_sc_hd__decap_3
X_5367_ _5367_/A0 _4734_/X _5388_/S VGND VGND VPWR VPWR _7149_/D sky130_fd_sc_hd__mux2_2
X_7106_ _7364_/CLK _7106_/D _6386_/Y VGND VGND VPWR VPWR _7106_/Q sky130_fd_sc_hd__dfrtp_2
X_5298_ _5298_/A0 _4734_/X _5310_/S VGND VGND VPWR VPWR _7181_/D sky130_fd_sc_hd__mux2_2
X_4318_ _7290_/Q _4534_/S _4348_/A2 _7162_/Q _4317_/X VGND VGND VPWR VPWR _4318_/X
+ sky130_fd_sc_hd__a221o_2
XFILLER_59_269 VGND VGND VPWR VPWR sky130_fd_sc_hd__decap_3
X_7037_ _7352_/CLK _7037_/D _6317_/Y VGND VGND VPWR VPWR _7037_/Q sky130_fd_sc_hd__dfrtp_2
X_4249_ _7069_/Q _4265_/B _4460_/A VGND VGND VPWR VPWR _4626_/C sky130_fd_sc_hd__o21a_2
XTAP_TAPCELL_ROW_58_905 VGND VPWR sky130_fd_sc_hd__tapvpwrvgnd_1
XFILLER_28_601 VGND VGND VPWR VPWR sky130_fd_sc_hd__decap_3
XFILLER_28_634 VGND VGND VPWR VPWR sky130_fd_sc_hd__decap_3
XFILLER_27_122 VGND VGND VPWR VPWR sky130_fd_sc_hd__decap_3
XFILLER_28_645 VGND VGND VPWR VPWR sky130_fd_sc_hd__decap_3
XTAP_TAPCELL_ROW_2_254 VGND VPWR sky130_fd_sc_hd__tapvpwrvgnd_1
XFILLER_15_306 VGND VGND VPWR VPWR sky130_fd_sc_hd__decap_3
XFILLER_27_177 VGND VGND VPWR VPWR sky130_fd_sc_hd__decap_3
XFILLER_35_34 VGND VGND VPWR VPWR sky130_fd_sc_hd__decap_3
XFILLER_43_626 VGND VGND VPWR VPWR sky130_fd_sc_hd__decap_3
XFILLER_70_401 VGND VGND VPWR VPWR sky130_fd_sc_hd__decap_3
XTAP_TAPCELL_ROW_38_673 VGND VPWR sky130_fd_sc_hd__tapvpwrvgnd_1
XTAP_TAPCELL_ROW_66_993 VGND VPWR sky130_fd_sc_hd__tapvpwrvgnd_1
XFILLER_42_147 VGND VGND VPWR VPWR sky130_fd_sc_hd__fill_2
XFILLER_70_467 VGND VGND VPWR VPWR sky130_fd_sc_hd__fill_1
XFILLER_11_567 VGND VGND VPWR VPWR sky130_fd_sc_hd__decap_3
XFILLER_50_191 VGND VGND VPWR VPWR sky130_fd_sc_hd__decap_3
XFILLER_51_44 VGND VGND VPWR VPWR sky130_fd_sc_hd__decap_3
XFILLER_7_505 VGND VGND VPWR VPWR sky130_fd_sc_hd__fill_2
XFILLER_7_516 VGND VGND VPWR VPWR sky130_fd_sc_hd__decap_3
XTAP_TAPCELL_ROW_94_1314 VGND VPWR sky130_fd_sc_hd__tapvpwrvgnd_1
XFILLER_2_265 VGND VGND VPWR VPWR sky130_fd_sc_hd__decap_3
XFILLER_104_171 VGND VGND VPWR VPWR sky130_fd_sc_hd__decap_3
XFILLER_2_276 VGND VGND VPWR VPWR sky130_fd_sc_hd__decap_3
XFILLER_19_612 VGND VGND VPWR VPWR sky130_fd_sc_hd__decap_3
XFILLER_19_623 VGND VGND VPWR VPWR sky130_fd_sc_hd__decap_3
XFILLER_65_217 VGND VGND VPWR VPWR sky130_fd_sc_hd__decap_3
XFILLER_65_228 VGND VGND VPWR VPWR sky130_fd_sc_hd__decap_3
XFILLER_78_589 VGND VGND VPWR VPWR sky130_fd_sc_hd__fill_1
XFILLER_93_537 VGND VGND VPWR VPWR sky130_fd_sc_hd__fill_2
XFILLER_18_111 VGND VGND VPWR VPWR sky130_fd_sc_hd__decap_3
XFILLER_18_144 VGND VGND VPWR VPWR sky130_fd_sc_hd__decap_3
XFILLER_18_177 VGND VGND VPWR VPWR sky130_fd_sc_hd__decap_3
XFILLER_34_626 VGND VGND VPWR VPWR sky130_fd_sc_hd__decap_3
XFILLER_80_209 VGND VGND VPWR VPWR sky130_fd_sc_hd__decap_3
XFILLER_33_169 VGND VGND VPWR VPWR sky130_fd_sc_hd__decap_3
XFILLER_61_478 VGND VGND VPWR VPWR sky130_fd_sc_hd__decap_3
XFILLER_92_95 VGND VGND VPWR VPWR sky130_fd_sc_hd__fill_1
XTAP_TAPCELL_ROW_103_1421 VGND VPWR sky130_fd_sc_hd__tapvpwrvgnd_1
XFILLER_14_361 VGND VGND VPWR VPWR sky130_fd_sc_hd__decap_3
X_3620_ _3620_/A _4292_/B _3620_/C VGND VGND VPWR VPWR _3620_/X sky130_fd_sc_hd__or3_4
X_3551_ _3508_/A _3547_/Y _3550_/X VGND VGND VPWR VPWR _3551_/X sky130_fd_sc_hd__a21o_2
XFILLER_6_560 VGND VGND VPWR VPWR sky130_fd_sc_hd__decap_3
XFILLER_51_3 VGND VGND VPWR VPWR sky130_fd_sc_hd__decap_3
X_6270_ _6364_/A VGND VGND VPWR VPWR _6270_/Y sky130_fd_sc_hd__inv_2
X_3482_ _3482_/A _3482_/B _3482_/C VGND VGND VPWR VPWR _3482_/Y sky130_fd_sc_hd__nor3_2
X_5221_ _5221_/A _5223_/B VGND VGND VPWR VPWR _7218_/D sky130_fd_sc_hd__and2_2
XFILLER_69_545 VGND VGND VPWR VPWR sky130_fd_sc_hd__decap_3
X_5152_ _7009_/Q _5152_/B VGND VGND VPWR VPWR _5152_/Y sky130_fd_sc_hd__nand2_2
XFILLER_84_504 VGND VGND VPWR VPWR sky130_fd_sc_hd__decap_3
X_4103_ _7365_/Q _4270_/B _4436_/B1 _7173_/Q VGND VGND VPWR VPWR _4103_/X sky130_fd_sc_hd__a22o_2
XFILLER_96_342 VGND VGND VPWR VPWR sky130_fd_sc_hd__decap_3
X_5083_ _5086_/A _4343_/X VGND VGND VPWR VPWR _5083_/X sky130_fd_sc_hd__or2b_2
XFILLER_96_397 VGND VGND VPWR VPWR sky130_fd_sc_hd__decap_3
XFILLER_2_82 VGND VGND VPWR VPWR sky130_fd_sc_hd__fill_2
XFILLER_37_420 VGND VGND VPWR VPWR sky130_fd_sc_hd__fill_1
XFILLER_84_548 VGND VGND VPWR VPWR sky130_fd_sc_hd__fill_1
X_4034_ _7150_/Q _4434_/B1 _4032_/X _4033_/X VGND VGND VPWR VPWR _4034_/X sky130_fd_sc_hd__a211o_2
XFILLER_25_615 VGND VGND VPWR VPWR sky130_fd_sc_hd__fill_1
XFILLER_25_626 VGND VGND VPWR VPWR sky130_fd_sc_hd__decap_3
XFILLER_52_412 VGND VGND VPWR VPWR sky130_fd_sc_hd__decap_3
XFILLER_64_294 VGND VGND VPWR VPWR sky130_fd_sc_hd__decap_3
XFILLER_92_592 VGND VGND VPWR VPWR sky130_fd_sc_hd__decap_3
XTAP_TAPCELL_ROW_35_632 VGND VPWR sky130_fd_sc_hd__tapvpwrvgnd_1
XFILLER_12_309 VGND VGND VPWR VPWR sky130_fd_sc_hd__decap_3
XFILLER_40_618 VGND VGND VPWR VPWR sky130_fd_sc_hd__decap_3
XTAP_TAPCELL_ROW_63_963 VGND VPWR sky130_fd_sc_hd__tapvpwrvgnd_1
X_4936_ _4936_/A _4936_/B VGND VGND VPWR VPWR _4936_/Y sky130_fd_sc_hd__xnor2_2
XANTENNA_10 _3900_/Y VGND VGND VPWR VPWR sky130_fd_sc_hd__diode_2
X_4867_ _6998_/Q _4912_/A VGND VGND VPWR VPWR _4882_/A sky130_fd_sc_hd__nand2_2
X_6606_ _6609_/A VGND VGND VPWR VPWR _6606_/Y sky130_fd_sc_hd__inv_2
X_3818_ _3818_/A1 _4799_/A _3817_/X VGND VGND VPWR VPWR _7390_/D sky130_fd_sc_hd__o21a_2
XFILLER_20_397 VGND VGND VPWR VPWR sky130_fd_sc_hd__decap_3
X_6537_ _6541_/A VGND VGND VPWR VPWR _6537_/Y sky130_fd_sc_hd__inv_2
X_4798_ _4811_/C _4795_/X _4796_/Y _4797_/X VGND VGND VPWR VPWR _5656_/A sky130_fd_sc_hd__a211o_2
X_3749_ _3726_/X _3734_/X _3748_/X _3896_/B1 VGND VGND VPWR VPWR _3749_/Y sky130_fd_sc_hd__o31ai_2
X_6468_ _6667_/A VGND VGND VPWR VPWR _6468_/Y sky130_fd_sc_hd__inv_2
X_6399_ _6630_/A VGND VGND VPWR VPWR _6399_/Y sky130_fd_sc_hd__inv_2
X_5419_ _5419_/A0 _5131_/X _5429_/S VGND VGND VPWR VPWR _7124_/D sky130_fd_sc_hd__mux2_2
XTAP_TAPCELL_ROW_7_313 VGND VPWR sky130_fd_sc_hd__tapvpwrvgnd_1
XFILLER_102_642 VGND VGND VPWR VPWR sky130_fd_sc_hd__fill_2
XFILLER_75_515 VGND VGND VPWR VPWR sky130_fd_sc_hd__decap_3
XFILLER_75_537 VGND VGND VPWR VPWR sky130_fd_sc_hd__decap_3
XFILLER_46_11 VGND VGND VPWR VPWR sky130_fd_sc_hd__fill_1
XFILLER_16_604 VGND VGND VPWR VPWR sky130_fd_sc_hd__decap_3
XFILLER_28_464 VGND VGND VPWR VPWR sky130_fd_sc_hd__decap_3
XFILLER_62_209 VGND VGND VPWR VPWR sky130_fd_sc_hd__decap_3
XFILLER_15_103 VGND VGND VPWR VPWR sky130_fd_sc_hd__decap_3
XFILLER_16_637 VGND VGND VPWR VPWR sky130_fd_sc_hd__decap_3
XFILLER_55_294 VGND VGND VPWR VPWR sky130_fd_sc_hd__decap_3
XFILLER_70_220 VGND VGND VPWR VPWR sky130_fd_sc_hd__decap_3
XFILLER_15_147 VGND VGND VPWR VPWR sky130_fd_sc_hd__decap_3
XFILLER_15_169 VGND VGND VPWR VPWR sky130_fd_sc_hd__decap_3
XFILLER_31_607 VGND VGND VPWR VPWR sky130_fd_sc_hd__decap_3
XFILLER_43_445 VGND VGND VPWR VPWR sky130_fd_sc_hd__decap_3
XFILLER_70_253 VGND VGND VPWR VPWR sky130_fd_sc_hd__decap_3
XFILLER_102_83 VGND VGND VPWR VPWR sky130_fd_sc_hd__fill_1
XFILLER_102_94 VGND VGND VPWR VPWR sky130_fd_sc_hd__decap_3
XFILLER_30_117 VGND VGND VPWR VPWR sky130_fd_sc_hd__fill_1
XFILLER_31_629 VGND VGND VPWR VPWR sky130_fd_sc_hd__decap_3
XFILLER_62_54 VGND VGND VPWR VPWR sky130_fd_sc_hd__decap_3
XFILLER_11_320 VGND VGND VPWR VPWR sky130_fd_sc_hd__decap_3
XFILLER_62_76 VGND VGND VPWR VPWR sky130_fd_sc_hd__decap_3
XFILLER_11_375 VGND VGND VPWR VPWR sky130_fd_sc_hd__decap_3
XFILLER_7_368 VGND VGND VPWR VPWR sky130_fd_sc_hd__decap_3
XFILLER_3_541 VGND VGND VPWR VPWR sky130_fd_sc_hd__decap_3
XFILLER_97_106 VGND VGND VPWR VPWR sky130_fd_sc_hd__decap_3
XFILLER_3_585 VGND VGND VPWR VPWR sky130_fd_sc_hd__decap_3
XFILLER_97_128 VGND VGND VPWR VPWR sky130_fd_sc_hd__decap_3
XFILLER_87_84 VGND VGND VPWR VPWR sky130_fd_sc_hd__decap_3
XFILLER_78_386 VGND VGND VPWR VPWR sky130_fd_sc_hd__fill_1
XFILLER_93_312 VGND VGND VPWR VPWR sky130_fd_sc_hd__decap_3
XFILLER_19_420 VGND VGND VPWR VPWR sky130_fd_sc_hd__decap_3
XFILLER_46_250 VGND VGND VPWR VPWR sky130_fd_sc_hd__fill_2
XFILLER_46_283 VGND VGND VPWR VPWR sky130_fd_sc_hd__decap_3
XFILLER_61_220 VGND VGND VPWR VPWR sky130_fd_sc_hd__decap_3
XFILLER_22_607 VGND VGND VPWR VPWR sky130_fd_sc_hd__decap_3
XFILLER_61_231 VGND VGND VPWR VPWR sky130_fd_sc_hd__decap_3
XFILLER_61_253 VGND VGND VPWR VPWR sky130_fd_sc_hd__decap_3
XTAP_TAPCELL_ROW_60_922 VGND VPWR sky130_fd_sc_hd__tapvpwrvgnd_1
XTAP_TAPCELL_ROW_32_602 VGND VPWR sky130_fd_sc_hd__tapvpwrvgnd_1
XFILLER_99_3 VGND VGND VPWR VPWR sky130_fd_sc_hd__decap_3
XFILLER_21_139 VGND VGND VPWR VPWR sky130_fd_sc_hd__decap_3
XFILLER_30_640 VGND VGND VPWR VPWR sky130_fd_sc_hd__decap_3
X_4721_ _5071_/A _4658_/A _4055_/A VGND VGND VPWR VPWR _4721_/Y sky130_fd_sc_hd__a21oi_2
X_4652_ _4652_/A _4652_/B VGND VGND VPWR VPWR _4785_/A sky130_fd_sc_hd__nor2_2
X_3603_ _4614_/B _3603_/B VGND VGND VPWR VPWR _3603_/Y sky130_fd_sc_hd__nand2_2
XTAP_TAPCELL_ROW_40_690 VGND VPWR sky130_fd_sc_hd__tapvpwrvgnd_1
XTAP_TAPCELL_ROW_12_370 VGND VPWR sky130_fd_sc_hd__tapvpwrvgnd_1
X_7371_ _7372_/CLK _7371_/D _6651_/Y VGND VGND VPWR VPWR _7371_/Q sky130_fd_sc_hd__dfrtp_2
Xhold803 _6910_/Q VGND VGND VPWR VPWR _6910_/D sky130_fd_sc_hd__dlygate4sd3_1
X_4583_ _4583_/A _4589_/B VGND VGND VPWR VPWR _7289_/D sky130_fd_sc_hd__and2_2
Xhold814 _6960_/Q VGND VGND VPWR VPWR _6960_/D sky130_fd_sc_hd__dlygate4sd3_1
Xhold825 _6891_/Q VGND VGND VPWR VPWR _6891_/D sky130_fd_sc_hd__dlygate4sd3_1
Xhold836 _6894_/Q VGND VGND VPWR VPWR _6894_/D sky130_fd_sc_hd__dlygate4sd3_1
X_6322_ _6680_/A VGND VGND VPWR VPWR _6322_/Y sky130_fd_sc_hd__inv_2
X_3534_ _3509_/Y _3510_/X _4285_/B1 VGND VGND VPWR VPWR _3534_/Y sky130_fd_sc_hd__a21oi_2
XFILLER_107_28 VGND VGND VPWR VPWR sky130_fd_sc_hd__decap_3
XFILLER_89_607 VGND VGND VPWR VPWR sky130_fd_sc_hd__decap_3
Xhold847 _7088_/Q VGND VGND VPWR VPWR _7088_/D sky130_fd_sc_hd__dlygate4sd3_1
Xhold858 _7074_/Q VGND VGND VPWR VPWR _7074_/D sky130_fd_sc_hd__dlygate4sd3_1
Xhold869 _7093_/Q VGND VGND VPWR VPWR _7093_/D sky130_fd_sc_hd__dlygate4sd3_1
Xmax_cap566 _6558_/A VGND VGND VPWR VPWR _6524_/A sky130_fd_sc_hd__clkbuf_2
Xmax_cap555 _4619_/Y VGND VGND VPWR VPWR _4625_/A2 sky130_fd_sc_hd__buf_1
X_3465_ _7185_/Q _3966_/S _3380_/Y _7377_/Q VGND VGND VPWR VPWR _3465_/X sky130_fd_sc_hd__a22o_2
XFILLER_88_128 VGND VGND VPWR VPWR sky130_fd_sc_hd__decap_3
XFILLER_97_640 VGND VGND VPWR VPWR sky130_fd_sc_hd__decap_3
XFILLER_29_217 VGND VGND VPWR VPWR sky130_fd_sc_hd__decap_3
XFILLER_69_364 VGND VGND VPWR VPWR sky130_fd_sc_hd__fill_2
XFILLER_84_301 VGND VGND VPWR VPWR sky130_fd_sc_hd__decap_3
XFILLER_84_312 VGND VGND VPWR VPWR sky130_fd_sc_hd__decap_3
X_5135_ _5135_/A1 _5642_/A _5595_/B _5134_/X VGND VGND VPWR VPWR _5135_/X sky130_fd_sc_hd__a211o_2
XFILLER_96_161 VGND VGND VPWR VPWR sky130_fd_sc_hd__decap_3
XFILLER_29_228 VGND VGND VPWR VPWR sky130_fd_sc_hd__decap_3
XFILLER_84_345 VGND VGND VPWR VPWR sky130_fd_sc_hd__decap_3
X_5066_ _5066_/A _5066_/B VGND VGND VPWR VPWR _6987_/D sky130_fd_sc_hd__nor2_2
XFILLER_37_250 VGND VGND VPWR VPWR sky130_fd_sc_hd__decap_3
X_4017_ _7310_/Q _4478_/S _4459_/C1 _7182_/Q VGND VGND VPWR VPWR _4017_/X sky130_fd_sc_hd__a22o_2
XFILLER_25_401 VGND VGND VPWR VPWR sky130_fd_sc_hd__fill_1
XTAP_TAPCELL_ROW_48_790 VGND VPWR sky130_fd_sc_hd__tapvpwrvgnd_1
XFILLER_25_445 VGND VGND VPWR VPWR sky130_fd_sc_hd__decap_3
XFILLER_52_253 VGND VGND VPWR VPWR sky130_fd_sc_hd__decap_3
XFILLER_13_629 VGND VGND VPWR VPWR sky130_fd_sc_hd__decap_3
XFILLER_25_478 VGND VGND VPWR VPWR sky130_fd_sc_hd__fill_2
XFILLER_25_489 VGND VGND VPWR VPWR sky130_fd_sc_hd__decap_3
XFILLER_52_286 VGND VGND VPWR VPWR sky130_fd_sc_hd__decap_3
XFILLER_80_595 VGND VGND VPWR VPWR sky130_fd_sc_hd__decap_3
X_4919_ _4937_/A _4936_/B _4938_/B VGND VGND VPWR VPWR _4920_/B sky130_fd_sc_hd__o21ba_2
XFILLER_20_150 VGND VGND VPWR VPWR sky130_fd_sc_hd__fill_2
XFILLER_20_183 VGND VGND VPWR VPWR sky130_fd_sc_hd__decap_3
XTAP_TAPCELL_ROW_78_1128 VGND VPWR sky130_fd_sc_hd__tapvpwrvgnd_1
XFILLER_4_327 VGND VGND VPWR VPWR sky130_fd_sc_hd__decap_3
XFILLER_0_522 VGND VGND VPWR VPWR sky130_fd_sc_hd__fill_2
XFILLER_106_277 VGND VGND VPWR VPWR sky130_fd_sc_hd__fill_2
XFILLER_0_533 VGND VGND VPWR VPWR sky130_fd_sc_hd__decap_3
XFILLER_102_472 VGND VGND VPWR VPWR sky130_fd_sc_hd__decap_3
XFILLER_57_43 VGND VGND VPWR VPWR sky130_fd_sc_hd__decap_3
XFILLER_75_301 VGND VGND VPWR VPWR sky130_fd_sc_hd__decap_3
XFILLER_87_161 VGND VGND VPWR VPWR sky130_fd_sc_hd__decap_3
XFILLER_87_172 VGND VGND VPWR VPWR sky130_fd_sc_hd__decap_3
XFILLER_75_334 VGND VGND VPWR VPWR sky130_fd_sc_hd__fill_2
XTAP_TAPCELL_ROW_89_1257 VGND VPWR sky130_fd_sc_hd__tapvpwrvgnd_1
XFILLER_90_315 VGND VGND VPWR VPWR sky130_fd_sc_hd__fill_1
XFILLER_90_348 VGND VGND VPWR VPWR sky130_fd_sc_hd__decap_3
XFILLER_16_456 VGND VGND VPWR VPWR sky130_fd_sc_hd__decap_3
XFILLER_31_415 VGND VGND VPWR VPWR sky130_fd_sc_hd__decap_3
XFILLER_12_640 VGND VGND VPWR VPWR sky130_fd_sc_hd__decap_3
XFILLER_11_150 VGND VGND VPWR VPWR sky130_fd_sc_hd__decap_3
XFILLER_8_622 VGND VGND VPWR VPWR sky130_fd_sc_hd__decap_3
XFILLER_11_172 VGND VGND VPWR VPWR sky130_fd_sc_hd__decap_3
XFILLER_7_110 VGND VGND VPWR VPWR sky130_fd_sc_hd__fill_2
XFILLER_7_187 VGND VGND VPWR VPWR sky130_fd_sc_hd__decap_3
XFILLER_3_360 VGND VGND VPWR VPWR sky130_fd_sc_hd__decap_3
XFILLER_98_83 VGND VGND VPWR VPWR sky130_fd_sc_hd__fill_1
XFILLER_3_393 VGND VGND VPWR VPWR sky130_fd_sc_hd__decap_3
XFILLER_100_409 VGND VGND VPWR VPWR sky130_fd_sc_hd__decap_3
XFILLER_39_526 VGND VGND VPWR VPWR sky130_fd_sc_hd__decap_3
XFILLER_66_312 VGND VGND VPWR VPWR sky130_fd_sc_hd__decap_3
XFILLER_78_150 VGND VGND VPWR VPWR sky130_fd_sc_hd__decap_3
XFILLER_14_3 VGND VGND VPWR VPWR sky130_fd_sc_hd__decap_3
XFILLER_26_209 VGND VGND VPWR VPWR sky130_fd_sc_hd__decap_3
XFILLER_54_507 VGND VGND VPWR VPWR sky130_fd_sc_hd__decap_3
X_6940_ _7083_/CLK _6940_/D VGND VGND VPWR VPWR _6940_/Q sky130_fd_sc_hd__dfxtp_2
XFILLER_81_315 VGND VGND VPWR VPWR sky130_fd_sc_hd__decap_3
XFILLER_81_337 VGND VGND VPWR VPWR sky130_fd_sc_hd__decap_3
XFILLER_93_175 VGND VGND VPWR VPWR sky130_fd_sc_hd__decap_3
X_6871_ clkload3/A _6871_/D VGND VGND VPWR VPWR _6871_/Q sky130_fd_sc_hd__dfxtp_2
XFILLER_34_275 VGND VGND VPWR VPWR sky130_fd_sc_hd__decap_3
XFILLER_34_286 VGND VGND VPWR VPWR sky130_fd_sc_hd__decap_3
X_4704_ _6994_/Q _4977_/A VGND VGND VPWR VPWR _4963_/A sky130_fd_sc_hd__and2_2
X_5684_ _7348_/Q hold910/X _5697_/S VGND VGND VPWR VPWR _6692_/D sky130_fd_sc_hd__mux2_2
XFILLER_8_70 VGND VGND VPWR VPWR sky130_fd_sc_hd__decap_3
X_4635_ _4916_/A _4916_/B _4633_/X _4634_/Y VGND VGND VPWR VPWR _4646_/A sky130_fd_sc_hd__a211o_2
X_7354_ _7356_/CLK _7354_/D _6634_/Y VGND VGND VPWR VPWR _7354_/Q sky130_fd_sc_hd__dfrtp_2
Xhold600 _6742_/Q VGND VGND VPWR VPWR _6742_/D sky130_fd_sc_hd__dlygate4sd3_1
Xhold611 _6958_/Q VGND VGND VPWR VPWR _6958_/D sky130_fd_sc_hd__dlygate4sd3_1
XFILLER_89_404 VGND VGND VPWR VPWR sky130_fd_sc_hd__decap_3
Xhold622 _6913_/Q VGND VGND VPWR VPWR _6913_/D sky130_fd_sc_hd__dlygate4sd3_1
Xhold633 _6919_/Q VGND VGND VPWR VPWR _6919_/D sky130_fd_sc_hd__dlygate4sd3_1
Xhold644 _6867_/Q VGND VGND VPWR VPWR _6867_/D sky130_fd_sc_hd__dlygate4sd3_1
X_6305_ _6622_/A VGND VGND VPWR VPWR _6305_/Y sky130_fd_sc_hd__inv_2
X_3517_ _3386_/B _3370_/Y _3516_/X VGND VGND VPWR VPWR _3525_/A sky130_fd_sc_hd__a21bo_2
XFILLER_103_203 VGND VGND VPWR VPWR sky130_fd_sc_hd__decap_3
XFILLER_103_225 VGND VGND VPWR VPWR sky130_fd_sc_hd__fill_2
X_7285_ _7350_/CLK _7285_/D _6565_/Y VGND VGND VPWR VPWR _7285_/Q sky130_fd_sc_hd__dfrtp_2
Xhold655 _6915_/Q VGND VGND VPWR VPWR _6915_/D sky130_fd_sc_hd__dlygate4sd3_1
Xhold666 _6952_/Q VGND VGND VPWR VPWR _6952_/D sky130_fd_sc_hd__dlygate4sd3_1
Xhold677 _6796_/Q VGND VGND VPWR VPWR _6796_/D sky130_fd_sc_hd__dlygate4sd3_1
Xhold688 _6965_/Q VGND VGND VPWR VPWR _6965_/D sky130_fd_sc_hd__dlygate4sd3_1
X_4497_ _7331_/Q _7299_/Q _4501_/S VGND VGND VPWR VPWR _7331_/D sky130_fd_sc_hd__mux2_2
Xhold699 _6757_/Q VGND VGND VPWR VPWR _6757_/D sky130_fd_sc_hd__dlygate4sd3_1
X_3448_ _7282_/Q _5142_/S _3409_/X _7154_/Q _3447_/X VGND VGND VPWR VPWR _3448_/X
+ sky130_fd_sc_hd__a221o_2
XTAP_TAPCELL_ROW_73_1069 VGND VPWR sky130_fd_sc_hd__tapvpwrvgnd_1
XFILLER_85_610 VGND VGND VPWR VPWR sky130_fd_sc_hd__decap_3
X_3379_ _7219_/Q _3377_/X _4341_/B1 _7123_/Q VGND VGND VPWR VPWR _3379_/X sky130_fd_sc_hd__a22o_2
XFILLER_97_470 VGND VGND VPWR VPWR sky130_fd_sc_hd__decap_3
X_5118_ _5118_/A _6984_/Q _5118_/C _5118_/D VGND VGND VPWR VPWR _5118_/X sky130_fd_sc_hd__or4_2
XFILLER_27_57 VGND VGND VPWR VPWR sky130_fd_sc_hd__decap_3
XFILLER_72_315 VGND VGND VPWR VPWR sky130_fd_sc_hd__decap_3
XFILLER_84_175 VGND VGND VPWR VPWR sky130_fd_sc_hd__decap_3
XFILLER_84_197 VGND VGND VPWR VPWR sky130_fd_sc_hd__decap_3
X_5049_ _5072_/B _5073_/B _5071_/B VGND VGND VPWR VPWR _5049_/X sky130_fd_sc_hd__a21bo_2
XFILLER_25_231 VGND VGND VPWR VPWR sky130_fd_sc_hd__decap_3
XFILLER_13_404 VGND VGND VPWR VPWR sky130_fd_sc_hd__decap_3
XFILLER_53_573 VGND VGND VPWR VPWR sky130_fd_sc_hd__decap_3
XFILLER_13_437 VGND VGND VPWR VPWR sky130_fd_sc_hd__decap_3
XFILLER_40_212 VGND VGND VPWR VPWR sky130_fd_sc_hd__decap_3
XTAP_TAPCELL_ROW_84_1198 VGND VPWR sky130_fd_sc_hd__tapvpwrvgnd_1
XFILLER_40_256 VGND VGND VPWR VPWR sky130_fd_sc_hd__decap_3
XFILLER_40_267 VGND VGND VPWR VPWR sky130_fd_sc_hd__decap_3
XFILLER_21_470 VGND VGND VPWR VPWR sky130_fd_sc_hd__fill_2
XTAP_TAPCELL_ROW_23_498 VGND VPWR sky130_fd_sc_hd__tapvpwrvgnd_1
XFILLER_21_492 VGND VGND VPWR VPWR sky130_fd_sc_hd__decap_3
XFILLER_5_603 VGND VGND VPWR VPWR sky130_fd_sc_hd__decap_3
XFILLER_4_124 VGND VGND VPWR VPWR sky130_fd_sc_hd__decap_3
XFILLER_5_647 VGND VGND VPWR VPWR sky130_fd_sc_hd__fill_1
XFILLER_107_564 VGND VGND VPWR VPWR sky130_fd_sc_hd__fill_1
XFILLER_108_60 VGND VGND VPWR VPWR sky130_fd_sc_hd__decap_3
XFILLER_0_330 VGND VGND VPWR VPWR sky130_fd_sc_hd__decap_3
XFILLER_88_470 VGND VGND VPWR VPWR sky130_fd_sc_hd__decap_3
XFILLER_0_396 VGND VGND VPWR VPWR sky130_fd_sc_hd__decap_3
XFILLER_102_280 VGND VGND VPWR VPWR sky130_fd_sc_hd__decap_3
XFILLER_48_312 VGND VGND VPWR VPWR sky130_fd_sc_hd__decap_3
XFILLER_76_632 VGND VGND VPWR VPWR sky130_fd_sc_hd__decap_3
XFILLER_75_142 VGND VGND VPWR VPWR sky130_fd_sc_hd__decap_3
XFILLER_48_389 VGND VGND VPWR VPWR sky130_fd_sc_hd__decap_3
XFILLER_63_337 VGND VGND VPWR VPWR sky130_fd_sc_hd__decap_3
XFILLER_75_164 VGND VGND VPWR VPWR sky130_fd_sc_hd__decap_3
XFILLER_75_175 VGND VGND VPWR VPWR sky130_fd_sc_hd__fill_2
Xplace304 _3605_/Y VGND VGND VPWR VPWR _5146_/B1 sky130_fd_sc_hd__buf_2
Xplace337 _5392_/S VGND VGND VPWR VPWR _5388_/S sky130_fd_sc_hd__buf_2
Xplace326 _5721_/S VGND VGND VPWR VPWR _5737_/S sky130_fd_sc_hd__buf_2
Xplace315 _5292_/S VGND VGND VPWR VPWR _5274_/S sky130_fd_sc_hd__buf_2
XFILLER_16_253 VGND VGND VPWR VPWR sky130_fd_sc_hd__decap_3
XFILLER_90_178 VGND VGND VPWR VPWR sky130_fd_sc_hd__decap_3
Xplace359 _4436_/B1 VGND VGND VPWR VPWR _4416_/B1 sky130_fd_sc_hd__buf_2
Xplace348 _4288_/B VGND VGND VPWR VPWR _4337_/B sky130_fd_sc_hd__buf_2
XFILLER_8_441 VGND VGND VPWR VPWR sky130_fd_sc_hd__fill_2
X_4420_ _7336_/Q _3943_/S _4420_/B1 _7144_/Q VGND VGND VPWR VPWR _4420_/X sky130_fd_sc_hd__a22o_2
X_4351_ _7097_/Q _4351_/A2 _4351_/B1 _7129_/Q VGND VGND VPWR VPWR _4351_/X sky130_fd_sc_hd__a22o_2
X_7070_ _7398_/CLK _7070_/D _6350_/Y VGND VGND VPWR VPWR _7070_/Q sky130_fd_sc_hd__dfrtp_2
X_4282_ _7062_/Q _3558_/B _3429_/X _4281_/X VGND VGND VPWR VPWR _4612_/A sky130_fd_sc_hd__o211ai_2
X_3302_ _3327_/B _5129_/B _6981_/Q VGND VGND VPWR VPWR _3302_/X sky130_fd_sc_hd__a21o_2
XFILLER_98_256 VGND VGND VPWR VPWR sky130_fd_sc_hd__decap_3
XFILLER_100_206 VGND VGND VPWR VPWR sky130_fd_sc_hd__decap_3
XFILLER_79_470 VGND VGND VPWR VPWR sky130_fd_sc_hd__decap_3
XFILLER_86_407 VGND VGND VPWR VPWR sky130_fd_sc_hd__decap_3
XFILLER_98_289 VGND VGND VPWR VPWR sky130_fd_sc_hd__fill_2
XFILLER_39_312 VGND VGND VPWR VPWR sky130_fd_sc_hd__decap_3
XFILLER_67_643 VGND VGND VPWR VPWR sky130_fd_sc_hd__decap_3
XFILLER_104_29 VGND VGND VPWR VPWR sky130_fd_sc_hd__decap_3
XFILLER_39_356 VGND VGND VPWR VPWR sky130_fd_sc_hd__decap_3
XFILLER_94_451 VGND VGND VPWR VPWR sky130_fd_sc_hd__decap_3
XFILLER_82_613 VGND VGND VPWR VPWR sky130_fd_sc_hd__fill_2
XFILLER_66_197 VGND VGND VPWR VPWR sky130_fd_sc_hd__fill_1
XFILLER_81_156 VGND VGND VPWR VPWR sky130_fd_sc_hd__decap_3
X_6923_ _6968_/CLK _6923_/D VGND VGND VPWR VPWR _6923_/Q sky130_fd_sc_hd__dfxtp_2
XFILLER_81_178 VGND VGND VPWR VPWR sky130_fd_sc_hd__decap_3
XFILLER_22_223 VGND VGND VPWR VPWR sky130_fd_sc_hd__decap_3
Xfanout27 _6559_/A VGND VGND VPWR VPWR _6625_/A sky130_fd_sc_hd__buf_2
Xfanout38 _6669_/A VGND VGND VPWR VPWR _6541_/A sky130_fd_sc_hd__buf_2
X_6854_ _6974_/CLK _6854_/D VGND VGND VPWR VPWR _6854_/Q sky130_fd_sc_hd__dfxtp_2
XFILLER_10_407 VGND VGND VPWR VPWR sky130_fd_sc_hd__decap_3
Xfanout49 _6677_/A VGND VGND VPWR VPWR _6684_/A sky130_fd_sc_hd__buf_2
X_6785_ _6963_/CLK _6785_/D VGND VGND VPWR VPWR _6785_/Q sky130_fd_sc_hd__dfxtp_2
XFILLER_22_289 VGND VGND VPWR VPWR sky130_fd_sc_hd__fill_2
X_5667_ _5667_/A _5668_/B VGND VGND VPWR VPWR _6979_/D sky130_fd_sc_hd__nor2_2
X_7406_ _7406_/CLK _7406_/D _6686_/Y VGND VGND VPWR VPWR _7406_/Q sky130_fd_sc_hd__dfrtp_2
XTAP_TAPCELL_ROW_20_468 VGND VPWR sky130_fd_sc_hd__tapvpwrvgnd_1
X_5598_ hold931/X _5587_/B _4468_/X VGND VGND VPWR VPWR _7028_/D sky130_fd_sc_hd__a21o_2
XFILLER_2_628 VGND VGND VPWR VPWR sky130_fd_sc_hd__decap_3
X_7337_ _7406_/CLK _7337_/D _6617_/Y VGND VGND VPWR VPWR _7337_/Q sky130_fd_sc_hd__dfrtp_2
XFILLER_104_545 VGND VGND VPWR VPWR sky130_fd_sc_hd__decap_3
XFILLER_1_149 VGND VGND VPWR VPWR sky130_fd_sc_hd__decap_3
XFILLER_89_223 VGND VGND VPWR VPWR sky130_fd_sc_hd__fill_1
XFILLER_89_234 VGND VGND VPWR VPWR sky130_fd_sc_hd__decap_3
X_7268_ _7357_/CLK _7268_/D _6548_/Y VGND VGND VPWR VPWR _7268_/Q sky130_fd_sc_hd__dfrtp_2
XFILLER_104_589 VGND VGND VPWR VPWR sky130_fd_sc_hd__decap_3
XFILLER_89_267 VGND VGND VPWR VPWR sky130_fd_sc_hd__decap_3
XFILLER_58_643 VGND VGND VPWR VPWR sky130_fd_sc_hd__fill_1
X_7199_ _7357_/CLK _7199_/D _6479_/Y VGND VGND VPWR VPWR _7199_/Q sky130_fd_sc_hd__dfrtp_2
XFILLER_38_67 VGND VGND VPWR VPWR sky130_fd_sc_hd__fill_1
Xhold1130 _7127_/Q VGND VGND VPWR VPWR _5413_/A0 sky130_fd_sc_hd__dlygate4sd3_1
Xhold1141 _7142_/Q VGND VGND VPWR VPWR _5381_/A0 sky130_fd_sc_hd__dlygate4sd3_1
XFILLER_45_315 VGND VGND VPWR VPWR sky130_fd_sc_hd__decap_3
XFILLER_85_495 VGND VGND VPWR VPWR sky130_fd_sc_hd__decap_3
Xhold1152 _7120_/Q VGND VGND VPWR VPWR _5427_/A0 sky130_fd_sc_hd__dlygate4sd3_1
Xhold1163 _7126_/Q VGND VGND VPWR VPWR _5415_/A0 sky130_fd_sc_hd__dlygate4sd3_1
Xhold1174 _7177_/Q VGND VGND VPWR VPWR _5306_/A0 sky130_fd_sc_hd__dlygate4sd3_1
Xhold1185 _7301_/Q VGND VGND VPWR VPWR _4559_/A sky130_fd_sc_hd__dlygate4sd3_1
XTAP_TAPCELL_ROW_86_1227 VGND VPWR sky130_fd_sc_hd__tapvpwrvgnd_1
XFILLER_45_348 VGND VGND VPWR VPWR sky130_fd_sc_hd__decap_3
XFILLER_57_197 VGND VGND VPWR VPWR sky130_fd_sc_hd__decap_3
Xhold1196 _7181_/Q VGND VGND VPWR VPWR _5298_/A0 sky130_fd_sc_hd__dlygate4sd3_1
XTAP_TAPCELL_ROW_28_557 VGND VPWR sky130_fd_sc_hd__tapvpwrvgnd_1
XFILLER_60_329 VGND VGND VPWR VPWR sky130_fd_sc_hd__decap_3
XFILLER_72_178 VGND VGND VPWR VPWR sky130_fd_sc_hd__fill_1
XTAP_TAPCELL_ROW_56_877 VGND VPWR sky130_fd_sc_hd__tapvpwrvgnd_1
XFILLER_13_201 VGND VGND VPWR VPWR sky130_fd_sc_hd__decap_3
XFILLER_13_234 VGND VGND VPWR VPWR sky130_fd_sc_hd__decap_3
XFILLER_26_584 VGND VGND VPWR VPWR sky130_fd_sc_hd__decap_3
XFILLER_53_381 VGND VGND VPWR VPWR sky130_fd_sc_hd__fill_2
XFILLER_54_88 VGND VGND VPWR VPWR sky130_fd_sc_hd__decap_3
XFILLER_9_205 VGND VGND VPWR VPWR sky130_fd_sc_hd__decap_3
XFILLER_5_422 VGND VGND VPWR VPWR sky130_fd_sc_hd__decap_3
Xclkload19 _7356_/CLK VGND VGND VPWR VPWR clkload19/X sky130_fd_sc_hd__clkbuf_1
XTAP_TAPCELL_ROW_97_1345 VGND VPWR sky130_fd_sc_hd__tapvpwrvgnd_1
XFILLER_79_74 VGND VGND VPWR VPWR sky130_fd_sc_hd__fill_2
XFILLER_95_204 VGND VGND VPWR VPWR sky130_fd_sc_hd__decap_3
XFILLER_49_632 VGND VGND VPWR VPWR sky130_fd_sc_hd__decap_3
XFILLER_95_237 VGND VGND VPWR VPWR sky130_fd_sc_hd__decap_3
XFILLER_48_153 VGND VGND VPWR VPWR sky130_fd_sc_hd__fill_1
XFILLER_76_462 VGND VGND VPWR VPWR sky130_fd_sc_hd__fill_2
XFILLER_48_164 VGND VGND VPWR VPWR sky130_fd_sc_hd__decap_3
XFILLER_64_635 VGND VGND VPWR VPWR sky130_fd_sc_hd__decap_3
XFILLER_76_495 VGND VGND VPWR VPWR sky130_fd_sc_hd__decap_3
XFILLER_36_359 VGND VGND VPWR VPWR sky130_fd_sc_hd__decap_3
XFILLER_48_197 VGND VGND VPWR VPWR sky130_fd_sc_hd__fill_1
Xplace112 _3665_/B VGND VGND VPWR VPWR place112/X sky130_fd_sc_hd__buf_2
XFILLER_91_476 VGND VGND VPWR VPWR sky130_fd_sc_hd__fill_1
XFILLER_91_487 VGND VGND VPWR VPWR sky130_fd_sc_hd__decap_3
X_3920_ hold971/X _5138_/S _3919_/X VGND VGND VPWR VPWR _7377_/D sky130_fd_sc_hd__o21a_2
XTAP_TAPCELL_ROW_106_1452 VGND VPWR sky130_fd_sc_hd__tapvpwrvgnd_1
XFILLER_44_381 VGND VGND VPWR VPWR sky130_fd_sc_hd__decap_3
XFILLER_32_565 VGND VGND VPWR VPWR sky130_fd_sc_hd__decap_3
X_3851_ _6825_/Q _3886_/A2 _3886_/B1 _6815_/Q _3850_/X VGND VGND VPWR VPWR _3851_/X
+ sky130_fd_sc_hd__a221o_2
XFILLER_32_598 VGND VGND VPWR VPWR sky130_fd_sc_hd__decap_3
XFILLER_81_3 VGND VGND VPWR VPWR sky130_fd_sc_hd__decap_3
X_6570_ _6601_/A VGND VGND VPWR VPWR _6570_/Y sky130_fd_sc_hd__inv_2
X_3782_ _6827_/Q _3852_/A2 _3853_/A2 _6817_/Q VGND VGND VPWR VPWR _3782_/X sky130_fd_sc_hd__a22o_2
XFILLER_8_271 VGND VGND VPWR VPWR sky130_fd_sc_hd__decap_3
XFILLER_8_293 VGND VGND VPWR VPWR sky130_fd_sc_hd__decap_3
Xoutput502 _3449_/C VGND VGND VPWR VPWR instruction_out[23] sky130_fd_sc_hd__clkdlybuf4s25_1
Xoutput535 _7003_/Q VGND VGND VPWR VPWR pc_out[26] sky130_fd_sc_hd__clkdlybuf4s25_1
Xoutput524 _6993_/Q VGND VGND VPWR VPWR pc_out[16] sky130_fd_sc_hd__clkdlybuf4s25_1
Xoutput513 _3339_/C1 VGND VGND VPWR VPWR instruction_out[6] sky130_fd_sc_hd__clkdlybuf4s25_1
X_5383_ _5383_/A0 _4878_/X _5392_/S VGND VGND VPWR VPWR _7141_/D sky130_fd_sc_hd__mux2_2
X_4403_ _4403_/A VGND VGND VPWR VPWR _4411_/A sky130_fd_sc_hd__inv_2
X_7122_ _7355_/CLK _7122_/D _6402_/Y VGND VGND VPWR VPWR _7122_/Q sky130_fd_sc_hd__dfrtp_2
Xoutput546 _6984_/Q VGND VGND VPWR VPWR pc_out[7] sky130_fd_sc_hd__clkdlybuf4s25_1
X_4334_ _7351_/Q _4337_/B _3409_/X _7159_/Q VGND VGND VPWR VPWR _4336_/B sky130_fd_sc_hd__a22o_2
XFILLER_99_554 VGND VGND VPWR VPWR sky130_fd_sc_hd__decap_3
XFILLER_99_532 VGND VGND VPWR VPWR sky130_fd_sc_hd__fill_2
XFILLER_5_93 VGND VGND VPWR VPWR sky130_fd_sc_hd__fill_1
X_7053_ _7276_/CLK _7053_/D _6333_/Y VGND VGND VPWR VPWR _7053_/Q sky130_fd_sc_hd__dfrtp_2
XFILLER_101_526 VGND VGND VPWR VPWR sky130_fd_sc_hd__decap_3
XFILLER_86_248 VGND VGND VPWR VPWR sky130_fd_sc_hd__decap_3
X_4265_ _7070_/Q _4265_/B VGND VGND VPWR VPWR _4376_/C sky130_fd_sc_hd__nor2_2
XTAP_TAPCELL_ROW_70_1039 VGND VPWR sky130_fd_sc_hd__tapvpwrvgnd_1
XFILLER_101_559 VGND VGND VPWR VPWR sky130_fd_sc_hd__fill_1
XFILLER_39_131 VGND VGND VPWR VPWR sky130_fd_sc_hd__fill_2
XFILLER_67_440 VGND VGND VPWR VPWR sky130_fd_sc_hd__decap_3
X_4196_ _7391_/Q _4261_/A2 _4998_/S _7295_/Q _4195_/X VGND VGND VPWR VPWR _4196_/X
+ sky130_fd_sc_hd__a221o_2
XFILLER_27_304 VGND VGND VPWR VPWR sky130_fd_sc_hd__decap_3
XFILLER_39_164 VGND VGND VPWR VPWR sky130_fd_sc_hd__decap_3
XFILLER_39_175 VGND VGND VPWR VPWR sky130_fd_sc_hd__fill_1
XFILLER_55_613 VGND VGND VPWR VPWR sky130_fd_sc_hd__decap_3
XFILLER_55_635 VGND VGND VPWR VPWR sky130_fd_sc_hd__decap_3
XFILLER_67_495 VGND VGND VPWR VPWR sky130_fd_sc_hd__decap_3
XFILLER_27_348 VGND VGND VPWR VPWR sky130_fd_sc_hd__decap_3
XFILLER_54_145 VGND VGND VPWR VPWR sky130_fd_sc_hd__fill_1
XFILLER_82_421 VGND VGND VPWR VPWR sky130_fd_sc_hd__decap_3
XFILLER_82_454 VGND VGND VPWR VPWR sky130_fd_sc_hd__decap_3
XFILLER_94_281 VGND VGND VPWR VPWR sky130_fd_sc_hd__decap_3
XFILLER_54_156 VGND VGND VPWR VPWR sky130_fd_sc_hd__decap_3
XFILLER_70_616 VGND VGND VPWR VPWR sky130_fd_sc_hd__decap_3
XFILLER_35_370 VGND VGND VPWR VPWR sky130_fd_sc_hd__decap_3
X_6906_ clkload9/A _6906_/D VGND VGND VPWR VPWR _6906_/Q sky130_fd_sc_hd__dfxtp_2
XTAP_TAPCELL_ROW_53_847 VGND VPWR sky130_fd_sc_hd__tapvpwrvgnd_1
XTAP_TAPCELL_ROW_25_527 VGND VPWR sky130_fd_sc_hd__tapvpwrvgnd_1
XFILLER_24_58 VGND VGND VPWR VPWR sky130_fd_sc_hd__decap_3
X_6837_ _6958_/CLK _6837_/D VGND VGND VPWR VPWR _6837_/Q sky130_fd_sc_hd__dfxtp_2
XFILLER_10_215 VGND VGND VPWR VPWR sky130_fd_sc_hd__decap_3
XFILLER_23_598 VGND VGND VPWR VPWR sky130_fd_sc_hd__decap_3
XFILLER_50_362 VGND VGND VPWR VPWR sky130_fd_sc_hd__fill_2
XTAP_TAPCELL_ROW_81_1168 VGND VPWR sky130_fd_sc_hd__tapvpwrvgnd_1
XFILLER_10_259 VGND VGND VPWR VPWR sky130_fd_sc_hd__decap_3
X_6768_ _6976_/CLK _6768_/D VGND VGND VPWR VPWR _6768_/Q sky130_fd_sc_hd__dfxtp_2
XFILLER_108_125 VGND VGND VPWR VPWR sky130_fd_sc_hd__decap_3
XFILLER_40_24 VGND VGND VPWR VPWR sky130_fd_sc_hd__decap_3
X_6699_ _7350_/CLK _6699_/D VGND VGND VPWR VPWR _6699_/Q sky130_fd_sc_hd__dfxtp_2
X_5719_ _7365_/Q hold915/X _5737_/S VGND VGND VPWR VPWR _6709_/D sky130_fd_sc_hd__mux2_2
XFILLER_108_158 VGND VGND VPWR VPWR sky130_fd_sc_hd__decap_3
XFILLER_40_46 VGND VGND VPWR VPWR sky130_fd_sc_hd__decap_3
XFILLER_49_11 VGND VGND VPWR VPWR sky130_fd_sc_hd__fill_1
XFILLER_104_353 VGND VGND VPWR VPWR sky130_fd_sc_hd__decap_3
XFILLER_104_386 VGND VGND VPWR VPWR sky130_fd_sc_hd__decap_3
XFILLER_77_237 VGND VGND VPWR VPWR sky130_fd_sc_hd__decap_3
XTAP_TAPCELL_ROW_92_1297 VGND VPWR sky130_fd_sc_hd__tapvpwrvgnd_1
XFILLER_105_50 VGND VGND VPWR VPWR sky130_fd_sc_hd__decap_3
XFILLER_1_18 VGND VGND VPWR VPWR sky130_fd_sc_hd__decap_3
XFILLER_49_99 VGND VGND VPWR VPWR sky130_fd_sc_hd__decap_3
XFILLER_58_440 VGND VGND VPWR VPWR sky130_fd_sc_hd__fill_1
XFILLER_105_72 VGND VGND VPWR VPWR sky130_fd_sc_hd__decap_3
XFILLER_46_635 VGND VGND VPWR VPWR sky130_fd_sc_hd__decap_3
XFILLER_58_462 VGND VGND VPWR VPWR sky130_fd_sc_hd__decap_3
XTAP_TAPCELL_ROW_5_296 VGND VPWR sky130_fd_sc_hd__tapvpwrvgnd_1
XFILLER_100_592 VGND VGND VPWR VPWR sky130_fd_sc_hd__fill_2
XFILLER_18_337 VGND VGND VPWR VPWR sky130_fd_sc_hd__fill_1
XFILLER_45_134 VGND VGND VPWR VPWR sky130_fd_sc_hd__fill_1
XFILLER_65_54 VGND VGND VPWR VPWR sky130_fd_sc_hd__fill_2
XFILLER_73_432 VGND VGND VPWR VPWR sky130_fd_sc_hd__decap_3
XFILLER_85_281 VGND VGND VPWR VPWR sky130_fd_sc_hd__fill_1
XFILLER_65_87 VGND VGND VPWR VPWR sky130_fd_sc_hd__fill_2
XFILLER_26_392 VGND VGND VPWR VPWR sky130_fd_sc_hd__decap_3
XFILLER_61_638 VGND VGND VPWR VPWR sky130_fd_sc_hd__decap_3
XFILLER_14_565 VGND VGND VPWR VPWR sky130_fd_sc_hd__decap_3
XFILLER_14_598 VGND VGND VPWR VPWR sky130_fd_sc_hd__decap_3
XFILLER_14_80 VGND VGND VPWR VPWR sky130_fd_sc_hd__decap_3
XTAP_TAPCELL_ROW_101_1393 VGND VPWR sky130_fd_sc_hd__tapvpwrvgnd_1
XFILLER_14_91 VGND VGND VPWR VPWR sky130_fd_sc_hd__fill_1
XFILLER_5_263 VGND VGND VPWR VPWR sky130_fd_sc_hd__decap_3
XFILLER_68_215 VGND VGND VPWR VPWR sky130_fd_sc_hd__decap_3
XFILLER_49_440 VGND VGND VPWR VPWR sky130_fd_sc_hd__fill_2
XFILLER_68_259 VGND VGND VPWR VPWR sky130_fd_sc_hd__decap_3
X_4050_ _7053_/Q _4488_/S _4437_/B1 _7405_/Q _4049_/X VGND VGND VPWR VPWR _4050_/X
+ sky130_fd_sc_hd__a221o_2
XFILLER_37_613 VGND VGND VPWR VPWR sky130_fd_sc_hd__decap_3
XFILLER_64_410 VGND VGND VPWR VPWR sky130_fd_sc_hd__decap_3
XFILLER_37_635 VGND VGND VPWR VPWR sky130_fd_sc_hd__decap_3
XFILLER_49_495 VGND VGND VPWR VPWR sky130_fd_sc_hd__decap_3
XFILLER_64_421 VGND VGND VPWR VPWR sky130_fd_sc_hd__fill_1
XFILLER_64_432 VGND VGND VPWR VPWR sky130_fd_sc_hd__decap_3
XFILLER_36_156 VGND VGND VPWR VPWR sky130_fd_sc_hd__decap_3
XFILLER_52_627 VGND VGND VPWR VPWR sky130_fd_sc_hd__decap_3
XFILLER_91_240 VGND VGND VPWR VPWR sky130_fd_sc_hd__decap_3
XFILLER_36_189 VGND VGND VPWR VPWR sky130_fd_sc_hd__decap_3
XFILLER_51_104 VGND VGND VPWR VPWR sky130_fd_sc_hd__fill_2
XFILLER_91_273 VGND VGND VPWR VPWR sky130_fd_sc_hd__decap_3
X_4952_ _4967_/B _4968_/A VGND VGND VPWR VPWR _4969_/C sky130_fd_sc_hd__or2b_2
X_3903_ _6782_/Q _3651_/Y _5660_/B _6692_/Q _3902_/X VGND VGND VPWR VPWR _3904_/B
+ sky130_fd_sc_hd__a221o_2
XTAP_TAPCELL_ROW_50_806 VGND VPWR sky130_fd_sc_hd__tapvpwrvgnd_1
XFILLER_32_384 VGND VGND VPWR VPWR sky130_fd_sc_hd__fill_1
X_6622_ _6622_/A VGND VGND VPWR VPWR _6622_/Y sky130_fd_sc_hd__inv_2
X_6553_ _6554_/A VGND VGND VPWR VPWR _6553_/Y sky130_fd_sc_hd__inv_2
X_3765_ _3629_/Y _3764_/X _3867_/B1 VGND VGND VPWR VPWR _4927_/B sky130_fd_sc_hd__o21a_2
X_6484_ _6485_/A VGND VGND VPWR VPWR _6484_/Y sky130_fd_sc_hd__inv_2
X_3696_ _6940_/Q _3862_/A2 _3824_/B1 _6804_/Q _3695_/X VGND VGND VPWR VPWR _3696_/X
+ sky130_fd_sc_hd__a221o_2
XTAP_TAPCELL_ROW_30_585 VGND VPWR sky130_fd_sc_hd__tapvpwrvgnd_1
XTAP_TAPCELL_ROW_30_574 VGND VPWR sky130_fd_sc_hd__tapvpwrvgnd_1
XFILLER_9_591 VGND VGND VPWR VPWR sky130_fd_sc_hd__decap_3
XFILLER_105_139 VGND VGND VPWR VPWR sky130_fd_sc_hd__decap_3
XFILLER_10_49 VGND VGND VPWR VPWR sky130_fd_sc_hd__fill_2
XFILLER_99_340 VGND VGND VPWR VPWR sky130_fd_sc_hd__decap_3
XFILLER_101_312 VGND VGND VPWR VPWR sky130_fd_sc_hd__decap_3
X_7105_ _7366_/CLK _7105_/D _6385_/Y VGND VGND VPWR VPWR _7105_/Q sky130_fd_sc_hd__dfrtp_2
X_4317_ _7322_/Q _3958_/S _4346_/B1 _7354_/Q _4347_/C1 VGND VGND VPWR VPWR _4317_/X
+ sky130_fd_sc_hd__a221o_2
XFILLER_101_334 VGND VGND VPWR VPWR sky130_fd_sc_hd__fill_2
XFILLER_101_345 VGND VGND VPWR VPWR sky130_fd_sc_hd__decap_3
XFILLER_19_47 VGND VGND VPWR VPWR sky130_fd_sc_hd__decap_3
XFILLER_59_259 VGND VGND VPWR VPWR sky130_fd_sc_hd__fill_1
X_7036_ _7383_/CLK _7036_/D _6316_/Y VGND VGND VPWR VPWR _7036_/Q sky130_fd_sc_hd__dfrtp_2
X_4248_ _4248_/A _4248_/B _4248_/C VGND VGND VPWR VPWR _4626_/B sky130_fd_sc_hd__or3_4
XTAP_TAPCELL_ROW_58_906 VGND VPWR sky130_fd_sc_hd__tapvpwrvgnd_1
XFILLER_101_367 VGND VGND VPWR VPWR sky130_fd_sc_hd__decap_3
XFILLER_19_69 VGND VGND VPWR VPWR sky130_fd_sc_hd__decap_3
XFILLER_28_613 VGND VGND VPWR VPWR sky130_fd_sc_hd__decap_3
XFILLER_55_421 VGND VGND VPWR VPWR sky130_fd_sc_hd__decap_3
XFILLER_67_281 VGND VGND VPWR VPWR sky130_fd_sc_hd__decap_3
X_4179_ _4173_/Y _4248_/A _4376_/A _4178_/Y VGND VGND VPWR VPWR _4186_/A sky130_fd_sc_hd__a211o_2
XTAP_TAPCELL_ROW_2_255 VGND VPWR sky130_fd_sc_hd__tapvpwrvgnd_1
XFILLER_82_251 VGND VGND VPWR VPWR sky130_fd_sc_hd__fill_1
XFILLER_15_318 VGND VGND VPWR VPWR sky130_fd_sc_hd__decap_3
XFILLER_35_46 VGND VGND VPWR VPWR sky130_fd_sc_hd__fill_2
XFILLER_42_126 VGND VGND VPWR VPWR sky130_fd_sc_hd__decap_3
XFILLER_43_638 VGND VGND VPWR VPWR sky130_fd_sc_hd__decap_3
XFILLER_70_413 VGND VGND VPWR VPWR sky130_fd_sc_hd__decap_3
XFILLER_70_424 VGND VGND VPWR VPWR sky130_fd_sc_hd__decap_3
XFILLER_70_435 VGND VGND VPWR VPWR sky130_fd_sc_hd__fill_1
XFILLER_82_295 VGND VGND VPWR VPWR sky130_fd_sc_hd__decap_3
XTAP_TAPCELL_ROW_66_994 VGND VPWR sky130_fd_sc_hd__tapvpwrvgnd_1
XTAP_TAPCELL_ROW_38_674 VGND VPWR sky130_fd_sc_hd__tapvpwrvgnd_1
XFILLER_70_446 VGND VGND VPWR VPWR sky130_fd_sc_hd__decap_3
XFILLER_23_351 VGND VGND VPWR VPWR sky130_fd_sc_hd__decap_3
XFILLER_11_546 VGND VGND VPWR VPWR sky130_fd_sc_hd__fill_1
Xclkbuf_3_3__f_clk clkbuf_0_clk/X VGND VGND VPWR VPWR clkload0/A sky130_fd_sc_hd__clkbuf_16
XPHY_EDGE_ROW_14_Right_14 VGND VGND VPWR VPWR sky130_fd_sc_hd__decap_3
XFILLER_11_579 VGND VGND VPWR VPWR sky130_fd_sc_hd__decap_3
XFILLER_51_67 VGND VGND VPWR VPWR sky130_fd_sc_hd__decap_3
XFILLER_7_528 VGND VGND VPWR VPWR sky130_fd_sc_hd__decap_3
XTAP_TAPCELL_ROW_94_1315 VGND VPWR sky130_fd_sc_hd__tapvpwrvgnd_1
XFILLER_104_150 VGND VGND VPWR VPWR sky130_fd_sc_hd__decap_3
XFILLER_104_183 VGND VGND VPWR VPWR sky130_fd_sc_hd__fill_1
XFILLER_78_546 VGND VGND VPWR VPWR sky130_fd_sc_hd__decap_3
XPHY_EDGE_ROW_23_Right_23 VGND VGND VPWR VPWR sky130_fd_sc_hd__decap_3
XFILLER_78_579 VGND VGND VPWR VPWR sky130_fd_sc_hd__fill_1
XFILLER_18_123 VGND VGND VPWR VPWR sky130_fd_sc_hd__decap_3
XFILLER_19_635 VGND VGND VPWR VPWR sky130_fd_sc_hd__decap_3
XFILLER_46_421 VGND VGND VPWR VPWR sky130_fd_sc_hd__decap_3
XFILLER_58_292 VGND VGND VPWR VPWR sky130_fd_sc_hd__decap_3
XFILLER_76_97 VGND VGND VPWR VPWR sky130_fd_sc_hd__decap_3
XFILLER_46_465 VGND VGND VPWR VPWR sky130_fd_sc_hd__decap_3
XFILLER_61_402 VGND VGND VPWR VPWR sky130_fd_sc_hd__decap_3
XFILLER_73_240 VGND VGND VPWR VPWR sky130_fd_sc_hd__decap_3
XFILLER_18_189 VGND VGND VPWR VPWR sky130_fd_sc_hd__decap_3
XFILLER_34_638 VGND VGND VPWR VPWR sky130_fd_sc_hd__decap_3
XFILLER_46_487 VGND VGND VPWR VPWR sky130_fd_sc_hd__decap_3
XFILLER_61_424 VGND VGND VPWR VPWR sky130_fd_sc_hd__decap_3
XFILLER_61_435 VGND VGND VPWR VPWR sky130_fd_sc_hd__decap_3
XFILLER_73_284 VGND VGND VPWR VPWR sky130_fd_sc_hd__decap_3
XFILLER_92_85 VGND VGND VPWR VPWR sky130_fd_sc_hd__decap_3
XTAP_TAPCELL_ROW_103_1422 VGND VPWR sky130_fd_sc_hd__tapvpwrvgnd_1
XPHY_EDGE_ROW_32_Right_32 VGND VGND VPWR VPWR sky130_fd_sc_hd__decap_3
XFILLER_41_181 VGND VGND VPWR VPWR sky130_fd_sc_hd__decap_3
X_3550_ _4614_/A _3547_/A _3547_/B _3548_/X VGND VGND VPWR VPWR _3550_/X sky130_fd_sc_hd__a31o_2
XFILLER_6_572 VGND VGND VPWR VPWR sky130_fd_sc_hd__decap_3
X_3481_ _7344_/Q _4337_/B _5063_/S _7280_/Q VGND VGND VPWR VPWR _3482_/C sky130_fd_sc_hd__a22o_2
XPHY_EDGE_ROW_41_Right_41 VGND VGND VPWR VPWR sky130_fd_sc_hd__decap_3
XFILLER_69_513 VGND VGND VPWR VPWR sky130_fd_sc_hd__decap_3
X_5151_ _5151_/A _5659_/B VGND VGND VPWR VPWR _5151_/X sky130_fd_sc_hd__or2_2
X_5082_ _6986_/Q _5098_/A VGND VGND VPWR VPWR _6986_/D sky130_fd_sc_hd__xor2_2
X_4102_ _7077_/Q _4102_/B VGND VGND VPWR VPWR _4141_/B sky130_fd_sc_hd__nor2_2
XFILLER_56_207 VGND VGND VPWR VPWR sky130_fd_sc_hd__decap_3
X_4033_ _7054_/Q _4488_/S _4437_/B1 _7406_/Q VGND VGND VPWR VPWR _4033_/X sky130_fd_sc_hd__a22o_2
XPHY_EDGE_ROW_16_Left_125 VGND VGND VPWR VPWR sky130_fd_sc_hd__decap_3
XFILLER_96_365 VGND VGND VPWR VPWR sky130_fd_sc_hd__decap_3
XTAP_TAPCELL_ROW_69_1030 VGND VPWR sky130_fd_sc_hd__tapvpwrvgnd_1
XFILLER_25_638 VGND VGND VPWR VPWR sky130_fd_sc_hd__decap_3
XFILLER_52_424 VGND VGND VPWR VPWR sky130_fd_sc_hd__decap_3
XFILLER_92_571 VGND VGND VPWR VPWR sky130_fd_sc_hd__decap_3
XPHY_EDGE_ROW_50_Right_50 VGND VGND VPWR VPWR sky130_fd_sc_hd__decap_3
XFILLER_24_137 VGND VGND VPWR VPWR sky130_fd_sc_hd__decap_3
XFILLER_52_446 VGND VGND VPWR VPWR sky130_fd_sc_hd__decap_3
XTAP_TAPCELL_ROW_63_964 VGND VPWR sky130_fd_sc_hd__tapvpwrvgnd_1
XTAP_TAPCELL_ROW_35_633 VGND VPWR sky130_fd_sc_hd__tapvpwrvgnd_1
X_4935_ _6995_/Q _4963_/A VGND VGND VPWR VPWR _6995_/D sky130_fd_sc_hd__xor2_2
XANTENNA_11 _4451_/B VGND VGND VPWR VPWR sky130_fd_sc_hd__diode_2
XFILLER_32_181 VGND VGND VPWR VPWR sky130_fd_sc_hd__decap_3
XPHY_EDGE_ROW_25_Left_134 VGND VGND VPWR VPWR sky130_fd_sc_hd__decap_3
XFILLER_20_365 VGND VGND VPWR VPWR sky130_fd_sc_hd__decap_3
X_6605_ _6636_/A VGND VGND VPWR VPWR _6605_/Y sky130_fd_sc_hd__inv_2
X_4797_ _5006_/A1 _4648_/A _4447_/A _5033_/B2 VGND VGND VPWR VPWR _4797_/X sky130_fd_sc_hd__a22o_2
X_3817_ _3927_/A1 _3816_/X _5104_/A VGND VGND VPWR VPWR _3817_/X sky130_fd_sc_hd__a21o_2
X_6536_ _6536_/A VGND VGND VPWR VPWR _6536_/Y sky130_fd_sc_hd__inv_2
X_3748_ _3735_/X _3738_/X _3740_/X _3927_/A1 _3747_/X VGND VGND VPWR VPWR _3748_/X
+ sky130_fd_sc_hd__a221o_2
XFILLER_4_509 VGND VGND VPWR VPWR sky130_fd_sc_hd__fill_1
X_6467_ _6625_/A VGND VGND VPWR VPWR _6467_/Y sky130_fd_sc_hd__inv_2
X_3679_ _6894_/Q VGND VGND VPWR VPWR _3679_/Y sky130_fd_sc_hd__inv_2
X_6398_ _6622_/A VGND VGND VPWR VPWR _6398_/Y sky130_fd_sc_hd__inv_2
XTAP_TAPCELL_ROW_7_314 VGND VPWR sky130_fd_sc_hd__tapvpwrvgnd_1
XFILLER_102_621 VGND VGND VPWR VPWR sky130_fd_sc_hd__decap_3
XPHY_EDGE_ROW_34_Left_143 VGND VGND VPWR VPWR sky130_fd_sc_hd__decap_3
XFILLER_99_181 VGND VGND VPWR VPWR sky130_fd_sc_hd__decap_3
XFILLER_87_343 VGND VGND VPWR VPWR sky130_fd_sc_hd__decap_3
XFILLER_75_505 VGND VGND VPWR VPWR sky130_fd_sc_hd__fill_2
XFILLER_87_365 VGND VGND VPWR VPWR sky130_fd_sc_hd__decap_3
XFILLER_87_376 VGND VGND VPWR VPWR sky130_fd_sc_hd__decap_3
XFILLER_101_175 VGND VGND VPWR VPWR sky130_fd_sc_hd__decap_3
XFILLER_28_421 VGND VGND VPWR VPWR sky130_fd_sc_hd__decap_3
XFILLER_28_432 VGND VGND VPWR VPWR sky130_fd_sc_hd__decap_3
X_7019_ _7397_/CLK _7019_/D _6299_/Y VGND VGND VPWR VPWR _7019_/Q sky130_fd_sc_hd__dfrtp_2
XFILLER_16_616 VGND VGND VPWR VPWR sky130_fd_sc_hd__decap_3
XFILLER_15_126 VGND VGND VPWR VPWR sky130_fd_sc_hd__fill_2
XFILLER_83_582 VGND VGND VPWR VPWR sky130_fd_sc_hd__fill_1
XFILLER_102_73 VGND VGND VPWR VPWR sky130_fd_sc_hd__fill_2
XPHY_EDGE_ROW_43_Left_152 VGND VGND VPWR VPWR sky130_fd_sc_hd__decap_3
XFILLER_11_332 VGND VGND VPWR VPWR sky130_fd_sc_hd__decap_3
XFILLER_23_181 VGND VGND VPWR VPWR sky130_fd_sc_hd__decap_3
XFILLER_30_129 VGND VGND VPWR VPWR sky130_fd_sc_hd__decap_3
XFILLER_11_343 VGND VGND VPWR VPWR sky130_fd_sc_hd__decap_3
XFILLER_7_325 VGND VGND VPWR VPWR sky130_fd_sc_hd__decap_3
XFILLER_3_553 VGND VGND VPWR VPWR sky130_fd_sc_hd__decap_3
XFILLER_3_564 VGND VGND VPWR VPWR sky130_fd_sc_hd__decap_3
XPHY_EDGE_ROW_52_Left_161 VGND VGND VPWR VPWR sky130_fd_sc_hd__decap_3
XFILLER_105_470 VGND VGND VPWR VPWR sky130_fd_sc_hd__decap_3
XFILLER_3_597 VGND VGND VPWR VPWR sky130_fd_sc_hd__decap_3
XFILLER_78_365 VGND VGND VPWR VPWR sky130_fd_sc_hd__fill_1
XFILLER_19_432 VGND VGND VPWR VPWR sky130_fd_sc_hd__decap_3
XFILLER_38_229 VGND VGND VPWR VPWR sky130_fd_sc_hd__fill_2
XFILLER_93_346 VGND VGND VPWR VPWR sky130_fd_sc_hd__decap_3
XFILLER_81_508 VGND VGND VPWR VPWR sky130_fd_sc_hd__decap_3
XFILLER_19_487 VGND VGND VPWR VPWR sky130_fd_sc_hd__decap_3
XFILLER_34_402 VGND VGND VPWR VPWR sky130_fd_sc_hd__decap_3
XFILLER_34_424 VGND VGND VPWR VPWR sky130_fd_sc_hd__decap_3
XFILLER_46_262 VGND VGND VPWR VPWR sky130_fd_sc_hd__decap_3
XPHY_EDGE_ROW_61_Left_170 VGND VGND VPWR VPWR sky130_fd_sc_hd__decap_3
XFILLER_22_619 VGND VGND VPWR VPWR sky130_fd_sc_hd__decap_3
XTAP_TAPCELL_ROW_60_923 VGND VPWR sky130_fd_sc_hd__tapvpwrvgnd_1
XTAP_TAPCELL_ROW_32_603 VGND VPWR sky130_fd_sc_hd__tapvpwrvgnd_1
XFILLER_14_170 VGND VGND VPWR VPWR sky130_fd_sc_hd__fill_1
XFILLER_14_181 VGND VGND VPWR VPWR sky130_fd_sc_hd__decap_3
Xclkbuf_leaf_41_clk clkbuf_leaf_7_clk/A VGND VGND VPWR VPWR _7383_/CLK sky130_fd_sc_hd__clkbuf_16
X_4720_ _4720_/A _4720_/B VGND VGND VPWR VPWR _4720_/X sky130_fd_sc_hd__xor2_2
X_4651_ _4813_/A _4810_/B VGND VGND VPWR VPWR _4652_/B sky130_fd_sc_hd__and2_2
X_3602_ _4614_/A _3547_/A _3547_/B _4614_/C _4613_/B VGND VGND VPWR VPWR _3603_/B
+ sky130_fd_sc_hd__a41o_2
XTAP_TAPCELL_ROW_12_371 VGND VPWR sky130_fd_sc_hd__tapvpwrvgnd_1
X_7370_ _7372_/CLK _7370_/D _6650_/Y VGND VGND VPWR VPWR _7370_/Q sky130_fd_sc_hd__dfrtp_2
XTAP_TAPCELL_ROW_40_691 VGND VPWR sky130_fd_sc_hd__tapvpwrvgnd_1
Xhold804 _6895_/Q VGND VGND VPWR VPWR _6895_/D sky130_fd_sc_hd__dlygate4sd3_1
Xhold815 _6892_/Q VGND VGND VPWR VPWR _6892_/D sky130_fd_sc_hd__dlygate4sd3_1
Xhold826 _6802_/Q VGND VGND VPWR VPWR _6802_/D sky130_fd_sc_hd__dlygate4sd3_1
Xhold837 _6942_/Q VGND VGND VPWR VPWR _6942_/D sky130_fd_sc_hd__dlygate4sd3_1
X_6321_ _6669_/A VGND VGND VPWR VPWR _6321_/Y sky130_fd_sc_hd__inv_2
XFILLER_6_391 VGND VGND VPWR VPWR sky130_fd_sc_hd__decap_3
Xhold848 _7102_/Q VGND VGND VPWR VPWR _7102_/D sky130_fd_sc_hd__dlygate4sd3_1
Xhold859 _7114_/Q VGND VGND VPWR VPWR _7114_/D sky130_fd_sc_hd__dlygate4sd3_1
Xmax_cap567 _6654_/A VGND VGND VPWR VPWR _6552_/A sky130_fd_sc_hd__buf_2
Xmax_cap556 _4620_/C VGND VGND VPWR VPWR _4987_/A sky130_fd_sc_hd__clkbuf_2
XFILLER_103_429 VGND VGND VPWR VPWR sky130_fd_sc_hd__fill_2
X_5203_ _5203_/A _5223_/B VGND VGND VPWR VPWR _7227_/D sky130_fd_sc_hd__and2_2
XFILLER_69_321 VGND VGND VPWR VPWR sky130_fd_sc_hd__decap_3
XFILLER_69_332 VGND VGND VPWR VPWR sky130_fd_sc_hd__decap_3
X_5134_ _3735_/A _3908_/X _3346_/A VGND VGND VPWR VPWR _5134_/X sky130_fd_sc_hd__o21a_2
X_3395_ _7059_/Q _4305_/B VGND VGND VPWR VPWR _3589_/B sky130_fd_sc_hd__nor2_2
XFILLER_69_376 VGND VGND VPWR VPWR sky130_fd_sc_hd__decap_3
XFILLER_84_324 VGND VGND VPWR VPWR sky130_fd_sc_hd__decap_3
X_5065_ _6986_/Q _5098_/A _6987_/Q VGND VGND VPWR VPWR _5066_/B sky130_fd_sc_hd__a21oi_2
XFILLER_37_240 VGND VGND VPWR VPWR sky130_fd_sc_hd__decap_3
XFILLER_72_519 VGND VGND VPWR VPWR sky130_fd_sc_hd__decap_3
XFILLER_84_357 VGND VGND VPWR VPWR sky130_fd_sc_hd__decap_3
XFILLER_84_368 VGND VGND VPWR VPWR sky130_fd_sc_hd__decap_3
XFILLER_37_262 VGND VGND VPWR VPWR sky130_fd_sc_hd__decap_3
XFILLER_37_284 VGND VGND VPWR VPWR sky130_fd_sc_hd__decap_3
XFILLER_52_210 VGND VGND VPWR VPWR sky130_fd_sc_hd__decap_3
XFILLER_16_37 VGND VGND VPWR VPWR sky130_fd_sc_hd__decap_3
XFILLER_92_390 VGND VGND VPWR VPWR sky130_fd_sc_hd__decap_3
XTAP_TAPCELL_ROW_48_791 VGND VPWR sky130_fd_sc_hd__tapvpwrvgnd_1
XFILLER_52_265 VGND VGND VPWR VPWR sky130_fd_sc_hd__fill_1
XFILLER_80_574 VGND VGND VPWR VPWR sky130_fd_sc_hd__decap_3
XFILLER_12_129 VGND VGND VPWR VPWR sky130_fd_sc_hd__decap_3
Xclkbuf_leaf_32_clk clkload0/A VGND VGND VPWR VPWR _7352_/CLK sky130_fd_sc_hd__clkbuf_16
X_4918_ _4918_/A _4918_/B VGND VGND VPWR VPWR _4936_/B sky130_fd_sc_hd__nor2_2
XFILLER_21_641 VGND VGND VPWR VPWR sky130_fd_sc_hd__decap_3
XFILLER_32_58 VGND VGND VPWR VPWR sky130_fd_sc_hd__fill_1
X_4849_ _4872_/A _4872_/B VGND VGND VPWR VPWR _4849_/Y sky130_fd_sc_hd__nor2_2
XFILLER_20_195 VGND VGND VPWR VPWR sky130_fd_sc_hd__fill_1
XTAP_TAPCELL_ROW_78_1129 VGND VPWR sky130_fd_sc_hd__tapvpwrvgnd_1
X_6519_ _6557_/A VGND VGND VPWR VPWR _6519_/Y sky130_fd_sc_hd__inv_2
XFILLER_0_545 VGND VGND VPWR VPWR sky130_fd_sc_hd__decap_3
XFILLER_88_641 VGND VGND VPWR VPWR sky130_fd_sc_hd__decap_3
XFILLER_0_567 VGND VGND VPWR VPWR sky130_fd_sc_hd__decap_3
XFILLER_0_589 VGND VGND VPWR VPWR sky130_fd_sc_hd__decap_3
XFILLER_102_451 VGND VGND VPWR VPWR sky130_fd_sc_hd__decap_3
XFILLER_48_516 VGND VGND VPWR VPWR sky130_fd_sc_hd__decap_3
XFILLER_87_140 VGND VGND VPWR VPWR sky130_fd_sc_hd__decap_3
XFILLER_75_313 VGND VGND VPWR VPWR sky130_fd_sc_hd__decap_3
XFILLER_75_346 VGND VGND VPWR VPWR sky130_fd_sc_hd__fill_2
XFILLER_87_184 VGND VGND VPWR VPWR sky130_fd_sc_hd__decap_3
XFILLER_57_99 VGND VGND VPWR VPWR sky130_fd_sc_hd__decap_3
XFILLER_63_508 VGND VGND VPWR VPWR sky130_fd_sc_hd__decap_3
XTAP_TAPCELL_ROW_89_1258 VGND VPWR sky130_fd_sc_hd__tapvpwrvgnd_1
XFILLER_16_402 VGND VGND VPWR VPWR sky130_fd_sc_hd__decap_3
XFILLER_28_251 VGND VGND VPWR VPWR sky130_fd_sc_hd__fill_1
XFILLER_28_262 VGND VGND VPWR VPWR sky130_fd_sc_hd__decap_3
XFILLER_28_273 VGND VGND VPWR VPWR sky130_fd_sc_hd__decap_3
XFILLER_56_560 VGND VGND VPWR VPWR sky130_fd_sc_hd__decap_3
XFILLER_28_295 VGND VGND VPWR VPWR sky130_fd_sc_hd__fill_2
XFILLER_43_221 VGND VGND VPWR VPWR sky130_fd_sc_hd__decap_3
XFILLER_71_585 VGND VGND VPWR VPWR sky130_fd_sc_hd__fill_1
XFILLER_31_427 VGND VGND VPWR VPWR sky130_fd_sc_hd__decap_3
XFILLER_43_287 VGND VGND VPWR VPWR sky130_fd_sc_hd__decap_3
Xclkbuf_leaf_23_clk clkload2/A VGND VGND VPWR VPWR _7363_/CLK sky130_fd_sc_hd__clkbuf_16
XFILLER_8_601 VGND VGND VPWR VPWR sky130_fd_sc_hd__decap_3
XFILLER_8_634 VGND VGND VPWR VPWR sky130_fd_sc_hd__decap_3
XFILLER_8_645 VGND VGND VPWR VPWR sky130_fd_sc_hd__decap_3
XFILLER_11_184 VGND VGND VPWR VPWR sky130_fd_sc_hd__decap_3
XFILLER_7_133 VGND VGND VPWR VPWR sky130_fd_sc_hd__fill_1
XFILLER_7_155 VGND VGND VPWR VPWR sky130_fd_sc_hd__decap_3
XFILLER_22_91 VGND VGND VPWR VPWR sky130_fd_sc_hd__decap_3
XFILLER_7_199 VGND VGND VPWR VPWR sky130_fd_sc_hd__decap_3
XFILLER_3_372 VGND VGND VPWR VPWR sky130_fd_sc_hd__decap_3
XFILLER_98_427 VGND VGND VPWR VPWR sky130_fd_sc_hd__decap_3
XFILLER_98_449 VGND VGND VPWR VPWR sky130_fd_sc_hd__decap_3
XFILLER_39_505 VGND VGND VPWR VPWR sky130_fd_sc_hd__fill_1
XFILLER_66_324 VGND VGND VPWR VPWR sky130_fd_sc_hd__decap_3
XFILLER_78_195 VGND VGND VPWR VPWR sky130_fd_sc_hd__fill_1
XFILLER_94_633 VGND VGND VPWR VPWR sky130_fd_sc_hd__decap_3
XFILLER_66_379 VGND VGND VPWR VPWR sky130_fd_sc_hd__decap_3
XFILLER_93_132 VGND VGND VPWR VPWR sky130_fd_sc_hd__fill_2
XFILLER_19_251 VGND VGND VPWR VPWR sky130_fd_sc_hd__decap_3
XFILLER_93_187 VGND VGND VPWR VPWR sky130_fd_sc_hd__decap_3
XFILLER_34_210 VGND VGND VPWR VPWR sky130_fd_sc_hd__decap_3
XFILLER_34_243 VGND VGND VPWR VPWR sky130_fd_sc_hd__decap_3
X_6870_ _6963_/CLK _6870_/D VGND VGND VPWR VPWR _6870_/Q sky130_fd_sc_hd__dfxtp_2
XTAP_TAPCELL_ROW_17_430 VGND VPWR sky130_fd_sc_hd__tapvpwrvgnd_1
XFILLER_22_416 VGND VGND VPWR VPWR sky130_fd_sc_hd__decap_3
XFILLER_62_574 VGND VGND VPWR VPWR sky130_fd_sc_hd__decap_3
XTAP_TAPCELL_ROW_45_750 VGND VPWR sky130_fd_sc_hd__tapvpwrvgnd_1
Xclkbuf_leaf_14_clk clkload1/A VGND VGND VPWR VPWR _6943_/CLK sky130_fd_sc_hd__clkbuf_16
X_4703_ _6992_/Q _6993_/Q _5001_/A VGND VGND VPWR VPWR _4977_/A sky130_fd_sc_hd__and3_2
X_4634_ _4937_/A _4920_/A _4967_/B _4950_/A VGND VGND VPWR VPWR _4634_/Y sky130_fd_sc_hd__nand4bb_2
X_7353_ _7356_/CLK _7353_/D _6633_/Y VGND VGND VPWR VPWR _7353_/Q sky130_fd_sc_hd__dfrtp_2
Xhold601 _6843_/Q VGND VGND VPWR VPWR _6843_/D sky130_fd_sc_hd__dlygate4sd3_1
Xhold612 _6920_/Q VGND VGND VPWR VPWR _6920_/D sky130_fd_sc_hd__dlygate4sd3_1
X_4565_ _4565_/A _4573_/B VGND VGND VPWR VPWR _7298_/D sky130_fd_sc_hd__and2_2
Xhold623 _6853_/Q VGND VGND VPWR VPWR _6853_/D sky130_fd_sc_hd__dlygate4sd3_1
Xhold634 _6951_/Q VGND VGND VPWR VPWR _6951_/D sky130_fd_sc_hd__dlygate4sd3_1
Xhold645 _6970_/Q VGND VGND VPWR VPWR _6970_/D sky130_fd_sc_hd__dlygate4sd3_1
X_6304_ _6556_/A VGND VGND VPWR VPWR _6304_/Y sky130_fd_sc_hd__inv_2
X_3516_ _5118_/A _5129_/B _5118_/D _3371_/A VGND VGND VPWR VPWR _3516_/X sky130_fd_sc_hd__a211o_2
XFILLER_89_438 VGND VGND VPWR VPWR sky130_fd_sc_hd__decap_3
X_7284_ _7350_/CLK _7284_/D _6564_/Y VGND VGND VPWR VPWR _7284_/Q sky130_fd_sc_hd__dfrtp_2
Xhold656 _6924_/Q VGND VGND VPWR VPWR _6924_/D sky130_fd_sc_hd__dlygate4sd3_1
Xhold667 _6840_/Q VGND VGND VPWR VPWR _6840_/D sky130_fd_sc_hd__dlygate4sd3_1
Xhold678 _6947_/Q VGND VGND VPWR VPWR _6947_/D sky130_fd_sc_hd__dlygate4sd3_1
XPHY_EDGE_ROW_4_Right_4 VGND VGND VPWR VPWR sky130_fd_sc_hd__decap_3
XFILLER_103_237 VGND VGND VPWR VPWR sky130_fd_sc_hd__decap_3
Xhold689 _6907_/Q VGND VGND VPWR VPWR _6907_/D sky130_fd_sc_hd__dlygate4sd3_1
X_3447_ _7090_/Q _4335_/B1 _3407_/X _7122_/Q VGND VGND VPWR VPWR _3447_/X sky130_fd_sc_hd__a22o_2
XFILLER_69_162 VGND VGND VPWR VPWR sky130_fd_sc_hd__decap_3
X_3378_ _3378_/A _5646_/A VGND VGND VPWR VPWR _5229_/C sky130_fd_sc_hd__nor2_2
XFILLER_57_313 VGND VGND VPWR VPWR sky130_fd_sc_hd__decap_3
XFILLER_85_644 VGND VGND VPWR VPWR sky130_fd_sc_hd__decap_3
X_5117_ _5595_/B _5658_/D wire549/X VGND VGND VPWR VPWR _5117_/X sky130_fd_sc_hd__or3b_2
XFILLER_97_482 VGND VGND VPWR VPWR sky130_fd_sc_hd__decap_3
XFILLER_27_25 VGND VGND VPWR VPWR sky130_fd_sc_hd__decap_3
XFILLER_84_154 VGND VGND VPWR VPWR sky130_fd_sc_hd__decap_3
X_5048_ _5086_/A _5085_/A2 _4621_/X VGND VGND VPWR VPWR _5073_/B sky130_fd_sc_hd__o21bai_2
XFILLER_72_305 VGND VGND VPWR VPWR sky130_fd_sc_hd__decap_3
XFILLER_72_327 VGND VGND VPWR VPWR sky130_fd_sc_hd__decap_3
XFILLER_84_187 VGND VGND VPWR VPWR sky130_fd_sc_hd__decap_3
XFILLER_53_541 VGND VGND VPWR VPWR sky130_fd_sc_hd__decap_3
XFILLER_13_416 VGND VGND VPWR VPWR sky130_fd_sc_hd__decap_3
XFILLER_25_243 VGND VGND VPWR VPWR sky130_fd_sc_hd__fill_1
XFILLER_25_254 VGND VGND VPWR VPWR sky130_fd_sc_hd__decap_3
XFILLER_13_449 VGND VGND VPWR VPWR sky130_fd_sc_hd__fill_1
XFILLER_25_287 VGND VGND VPWR VPWR sky130_fd_sc_hd__decap_3
XFILLER_40_224 VGND VGND VPWR VPWR sky130_fd_sc_hd__fill_1
X_6999_ _7269_/CLK _6999_/D _6279_/Y VGND VGND VPWR VPWR _6999_/Q sky130_fd_sc_hd__dfrtp_2
XTAP_TAPCELL_ROW_84_1199 VGND VPWR sky130_fd_sc_hd__tapvpwrvgnd_1
XFILLER_40_246 VGND VGND VPWR VPWR sky130_fd_sc_hd__decap_3
XFILLER_43_57 VGND VGND VPWR VPWR sky130_fd_sc_hd__decap_3
XTAP_TAPCELL_ROW_23_499 VGND VPWR sky130_fd_sc_hd__tapvpwrvgnd_1
XFILLER_5_615 VGND VGND VPWR VPWR sky130_fd_sc_hd__fill_1
XFILLER_5_626 VGND VGND VPWR VPWR sky130_fd_sc_hd__decap_3
XFILLER_4_136 VGND VGND VPWR VPWR sky130_fd_sc_hd__decap_3
XFILLER_4_29 VGND VGND VPWR VPWR sky130_fd_sc_hd__fill_2
XFILLER_0_320 VGND VGND VPWR VPWR sky130_fd_sc_hd__fill_1
XFILLER_108_83 VGND VGND VPWR VPWR sky130_fd_sc_hd__fill_1
XFILLER_0_353 VGND VGND VPWR VPWR sky130_fd_sc_hd__decap_3
XFILLER_48_302 VGND VGND VPWR VPWR sky130_fd_sc_hd__decap_3
XFILLER_76_600 VGND VGND VPWR VPWR sky130_fd_sc_hd__decap_3
XFILLER_88_460 VGND VGND VPWR VPWR sky130_fd_sc_hd__decap_3
XFILLER_102_270 VGND VGND VPWR VPWR sky130_fd_sc_hd__fill_2
XFILLER_48_335 VGND VGND VPWR VPWR sky130_fd_sc_hd__decap_3
XFILLER_90_102 VGND VGND VPWR VPWR sky130_fd_sc_hd__decap_3
XFILLER_91_636 VGND VGND VPWR VPWR sky130_fd_sc_hd__decap_3
XFILLER_16_210 VGND VGND VPWR VPWR sky130_fd_sc_hd__decap_3
XFILLER_29_593 VGND VGND VPWR VPWR sky130_fd_sc_hd__decap_3
XFILLER_44_541 VGND VGND VPWR VPWR sky130_fd_sc_hd__decap_3
Xplace327 _5697_/S VGND VGND VPWR VPWR _5721_/S sky130_fd_sc_hd__buf_2
Xplace316 _4327_/A VGND VGND VPWR VPWR _4425_/A sky130_fd_sc_hd__buf_2
Xplace305 _4764_/Y VGND VGND VPWR VPWR _4788_/A sky130_fd_sc_hd__buf_2
XFILLER_16_265 VGND VGND VPWR VPWR sky130_fd_sc_hd__fill_2
XFILLER_17_91 VGND VGND VPWR VPWR sky130_fd_sc_hd__decap_3
XFILLER_44_563 VGND VGND VPWR VPWR sky130_fd_sc_hd__fill_1
XFILLER_90_157 VGND VGND VPWR VPWR sky130_fd_sc_hd__decap_3
Xplace349 _4351_/A2 VGND VGND VPWR VPWR _4434_/A2 sky130_fd_sc_hd__buf_2
Xplace338 _5400_/S VGND VGND VPWR VPWR _5392_/S sky130_fd_sc_hd__buf_2
XFILLER_31_213 VGND VGND VPWR VPWR sky130_fd_sc_hd__decap_3
XFILLER_31_235 VGND VGND VPWR VPWR sky130_fd_sc_hd__decap_3
XFILLER_44_585 VGND VGND VPWR VPWR sky130_fd_sc_hd__decap_3
XTAP_TAPCELL_ROW_42_720 VGND VPWR sky130_fd_sc_hd__tapvpwrvgnd_1
XTAP_TAPCELL_ROW_14_400 VGND VPWR sky130_fd_sc_hd__tapvpwrvgnd_1
XFILLER_31_279 VGND VGND VPWR VPWR sky130_fd_sc_hd__fill_1
XFILLER_8_464 VGND VGND VPWR VPWR sky130_fd_sc_hd__decap_3
XFILLER_8_486 VGND VGND VPWR VPWR sky130_fd_sc_hd__decap_3
X_4350_ _7065_/Q _4305_/B _4460_/A VGND VGND VPWR VPWR _4367_/B sky130_fd_sc_hd__o21a_2
X_3301_ _6981_/Q _3327_/B VGND VGND VPWR VPWR _3519_/B sky130_fd_sc_hd__nand2_4
X_4281_ _7254_/Q _4599_/S _4278_/X _4280_/X VGND VGND VPWR VPWR _4281_/X sky130_fd_sc_hd__a211o_2
XFILLER_98_246 VGND VGND VPWR VPWR sky130_fd_sc_hd__decap_3
XFILLER_98_224 VGND VGND VPWR VPWR sky130_fd_sc_hd__decap_3
XFILLER_67_600 VGND VGND VPWR VPWR sky130_fd_sc_hd__decap_3
XFILLER_86_419 VGND VGND VPWR VPWR sky130_fd_sc_hd__fill_1
Xclkbuf_leaf_3_clk clkbuf_leaf_7_clk/A VGND VGND VPWR VPWR _6963_/CLK sky130_fd_sc_hd__clkbuf_16
XFILLER_98_268 VGND VGND VPWR VPWR sky130_fd_sc_hd__decap_3
XFILLER_39_335 VGND VGND VPWR VPWR sky130_fd_sc_hd__fill_1
XFILLER_79_482 VGND VGND VPWR VPWR sky130_fd_sc_hd__decap_3
XFILLER_39_368 VGND VGND VPWR VPWR sky130_fd_sc_hd__decap_3
XFILLER_81_102 VGND VGND VPWR VPWR sky130_fd_sc_hd__decap_3
XFILLER_94_474 VGND VGND VPWR VPWR sky130_fd_sc_hd__fill_2
XFILLER_94_496 VGND VGND VPWR VPWR sky130_fd_sc_hd__decap_3
XFILLER_81_135 VGND VGND VPWR VPWR sky130_fd_sc_hd__decap_3
X_6922_ clkload8/A _6922_/D VGND VGND VPWR VPWR _6922_/Q sky130_fd_sc_hd__dfxtp_2
X_6853_ clkload7/A _6853_/D VGND VGND VPWR VPWR _6853_/Q sky130_fd_sc_hd__dfxtp_2
XFILLER_50_533 VGND VGND VPWR VPWR sky130_fd_sc_hd__decap_3
XFILLER_62_382 VGND VGND VPWR VPWR sky130_fd_sc_hd__decap_3
Xfanout28 _6559_/A VGND VGND VPWR VPWR _6632_/A sky130_fd_sc_hd__buf_2
XFILLER_22_235 VGND VGND VPWR VPWR sky130_fd_sc_hd__fill_1
XFILLER_50_544 VGND VGND VPWR VPWR sky130_fd_sc_hd__decap_3
Xfanout39 _6637_/A VGND VGND VPWR VPWR _6669_/A sky130_fd_sc_hd__buf_2
X_6784_ clkload6/A _6784_/D VGND VGND VPWR VPWR _6784_/Q sky130_fd_sc_hd__dfxtp_2
X_3996_ _7344_/Q _4534_/A0 _3996_/S VGND VGND VPWR VPWR _7344_/D sky130_fd_sc_hd__mux2_2
XFILLER_10_419 VGND VGND VPWR VPWR sky130_fd_sc_hd__fill_1
XFILLER_50_599 VGND VGND VPWR VPWR sky130_fd_sc_hd__decap_3
X_5735_ _7373_/Q hold913/X _5737_/S VGND VGND VPWR VPWR _6717_/D sky130_fd_sc_hd__mux2_2
XFILLER_13_49 VGND VGND VPWR VPWR sky130_fd_sc_hd__decap_3
X_5666_ _5666_/A _5666_/B VGND VGND VPWR VPWR _5668_/B sky130_fd_sc_hd__or2_2
X_7405_ _7405_/CLK _7405_/D _6685_/Y VGND VGND VPWR VPWR _7405_/Q sky130_fd_sc_hd__dfrtp_2
X_4617_ _5114_/B _4617_/B _4617_/C VGND VGND VPWR VPWR _5099_/A sky130_fd_sc_hd__or3_4
XTAP_TAPCELL_ROW_20_469 VGND VPWR sky130_fd_sc_hd__tapvpwrvgnd_1
X_5597_ hold948/X _5587_/B _5154_/Y VGND VGND VPWR VPWR _7029_/D sky130_fd_sc_hd__a21o_2
XFILLER_1_106 VGND VGND VPWR VPWR sky130_fd_sc_hd__decap_3
XFILLER_2_607 VGND VGND VPWR VPWR sky130_fd_sc_hd__decap_3
XFILLER_89_213 VGND VGND VPWR VPWR sky130_fd_sc_hd__decap_3
X_7336_ _7374_/CLK _7336_/D _6616_/Y VGND VGND VPWR VPWR _7336_/Q sky130_fd_sc_hd__dfrtp_2
X_4548_ _4548_/A _4563_/B VGND VGND VPWR VPWR _7306_/D sky130_fd_sc_hd__and2_2
X_7267_ _7269_/CLK _7267_/D _6547_/Y VGND VGND VPWR VPWR _7267_/Q sky130_fd_sc_hd__dfrtp_2
XPHY_EDGE_ROW_8_Left_117 VGND VGND VPWR VPWR sky130_fd_sc_hd__decap_3
XFILLER_38_35 VGND VGND VPWR VPWR sky130_fd_sc_hd__decap_3
XFILLER_58_622 VGND VGND VPWR VPWR sky130_fd_sc_hd__decap_3
X_7198_ _7392_/CLK _7198_/D _6478_/Y VGND VGND VPWR VPWR _7198_/Q sky130_fd_sc_hd__dfrtp_2
XFILLER_57_143 VGND VGND VPWR VPWR sky130_fd_sc_hd__fill_1
XFILLER_85_430 VGND VGND VPWR VPWR sky130_fd_sc_hd__decap_3
XFILLER_85_452 VGND VGND VPWR VPWR sky130_fd_sc_hd__decap_3
Xhold1120 _7178_/Q VGND VGND VPWR VPWR _5304_/A0 sky130_fd_sc_hd__dlygate4sd3_1
Xhold1131 _7245_/Q VGND VGND VPWR VPWR _5165_/A sky130_fd_sc_hd__dlygate4sd3_1
Xhold1142 _7169_/Q VGND VGND VPWR VPWR _5323_/A0 sky130_fd_sc_hd__dlygate4sd3_1
XFILLER_72_113 VGND VGND VPWR VPWR sky130_fd_sc_hd__decap_3
XFILLER_73_614 VGND VGND VPWR VPWR sky130_fd_sc_hd__fill_2
XFILLER_73_636 VGND VGND VPWR VPWR sky130_fd_sc_hd__decap_3
Xhold1153 _7336_/Q VGND VGND VPWR VPWR _4486_/A0 sky130_fd_sc_hd__dlygate4sd3_1
Xhold1164 _7139_/Q VGND VGND VPWR VPWR _5388_/A0 sky130_fd_sc_hd__dlygate4sd3_1
Xhold1175 _7221_/Q VGND VGND VPWR VPWR _5215_/A sky130_fd_sc_hd__dlygate4sd3_1
XTAP_TAPCELL_ROW_86_1228 VGND VPWR sky130_fd_sc_hd__tapvpwrvgnd_1
XPHY_EDGE_ROW_79_Right_79 VGND VGND VPWR VPWR sky130_fd_sc_hd__decap_3
Xhold1186 _7158_/Q VGND VGND VPWR VPWR _5346_/A0 sky130_fd_sc_hd__dlygate4sd3_1
Xhold1197 _7143_/Q VGND VGND VPWR VPWR _5379_/A0 sky130_fd_sc_hd__dlygate4sd3_1
XFILLER_54_45 VGND VGND VPWR VPWR sky130_fd_sc_hd__decap_3
XTAP_TAPCELL_ROW_56_878 VGND VPWR sky130_fd_sc_hd__tapvpwrvgnd_1
XTAP_TAPCELL_ROW_28_558 VGND VPWR sky130_fd_sc_hd__tapvpwrvgnd_1
XFILLER_13_213 VGND VGND VPWR VPWR sky130_fd_sc_hd__decap_3
XFILLER_26_596 VGND VGND VPWR VPWR sky130_fd_sc_hd__decap_3
XFILLER_80_190 VGND VGND VPWR VPWR sky130_fd_sc_hd__decap_3
XFILLER_41_588 VGND VGND VPWR VPWR sky130_fd_sc_hd__decap_3
XFILLER_9_228 VGND VGND VPWR VPWR sky130_fd_sc_hd__decap_3
XFILLER_70_88 VGND VGND VPWR VPWR sky130_fd_sc_hd__decap_3
XTAP_TAPCELL_ROW_97_1346 VGND VPWR sky130_fd_sc_hd__tapvpwrvgnd_1
XPHY_EDGE_ROW_88_Right_88 VGND VGND VPWR VPWR sky130_fd_sc_hd__decap_3
XFILLER_5_434 VGND VGND VPWR VPWR sky130_fd_sc_hd__decap_3
XFILLER_79_31 VGND VGND VPWR VPWR sky130_fd_sc_hd__fill_1
XFILLER_68_419 VGND VGND VPWR VPWR sky130_fd_sc_hd__fill_1
XFILLER_0_161 VGND VGND VPWR VPWR sky130_fd_sc_hd__decap_3
XFILLER_95_216 VGND VGND VPWR VPWR sky130_fd_sc_hd__decap_3
XFILLER_0_183 VGND VGND VPWR VPWR sky130_fd_sc_hd__decap_3
XFILLER_49_644 VGND VGND VPWR VPWR sky130_fd_sc_hd__decap_3
XFILLER_76_441 VGND VGND VPWR VPWR sky130_fd_sc_hd__decap_3
XFILLER_88_290 VGND VGND VPWR VPWR sky130_fd_sc_hd__decap_3
XPHY_EDGE_ROW_97_Right_97 VGND VGND VPWR VPWR sky130_fd_sc_hd__decap_3
XFILLER_95_63 VGND VGND VPWR VPWR sky130_fd_sc_hd__decap_3
XFILLER_76_474 VGND VGND VPWR VPWR sky130_fd_sc_hd__fill_2
XFILLER_91_422 VGND VGND VPWR VPWR sky130_fd_sc_hd__decap_3
XFILLER_91_444 VGND VGND VPWR VPWR sky130_fd_sc_hd__decap_3
XFILLER_91_455 VGND VGND VPWR VPWR sky130_fd_sc_hd__decap_3
XTAP_TAPCELL_ROW_106_1453 VGND VPWR sky130_fd_sc_hd__tapvpwrvgnd_1
XFILLER_17_585 VGND VGND VPWR VPWR sky130_fd_sc_hd__decap_3
XFILLER_32_533 VGND VGND VPWR VPWR sky130_fd_sc_hd__fill_2
XFILLER_44_360 VGND VGND VPWR VPWR sky130_fd_sc_hd__decap_3
XFILLER_44_393 VGND VGND VPWR VPWR sky130_fd_sc_hd__decap_3
XFILLER_91_499 VGND VGND VPWR VPWR sky130_fd_sc_hd__decap_3
X_3850_ _6810_/Q _3656_/Y _3852_/B1 _6820_/Q VGND VGND VPWR VPWR _3850_/X sky130_fd_sc_hd__a22o_2
XFILLER_32_577 VGND VGND VPWR VPWR sky130_fd_sc_hd__decap_3
X_3781_ _6949_/Q _3656_/Y _3887_/B1 _6961_/Q _3780_/X VGND VGND VPWR VPWR _3781_/X
+ sky130_fd_sc_hd__a221o_2
XFILLER_12_290 VGND VGND VPWR VPWR sky130_fd_sc_hd__fill_2
XFILLER_74_3 VGND VGND VPWR VPWR sky130_fd_sc_hd__decap_3
Xoutput536 _7004_/Q VGND VGND VPWR VPWR pc_out[27] sky130_fd_sc_hd__clkdlybuf4s25_1
Xoutput525 _6994_/Q VGND VGND VPWR VPWR pc_out[17] sky130_fd_sc_hd__clkdlybuf4s25_1
Xoutput514 _5229_/B VGND VGND VPWR VPWR instruction_out[7] sky130_fd_sc_hd__clkdlybuf4s25_1
Xoutput503 _4528_/B VGND VGND VPWR VPWR instruction_out[24] sky130_fd_sc_hd__clkdlybuf4s25_1
X_4402_ _7082_/Q _4102_/B _4432_/B1 _4401_/X VGND VGND VPWR VPWR _4403_/A sky130_fd_sc_hd__o211a_2
XFILLER_99_511 VGND VGND VPWR VPWR sky130_fd_sc_hd__fill_2
X_7121_ _7376_/CLK _7121_/D _6401_/Y VGND VGND VPWR VPWR _7121_/Q sky130_fd_sc_hd__dfrtp_2
Xoutput547 _6985_/Q VGND VGND VPWR VPWR pc_out[8] sky130_fd_sc_hd__clkdlybuf4s25_1
X_4333_ _7127_/Q _4351_/B1 _4332_/X VGND VGND VPWR VPWR _4336_/A sky130_fd_sc_hd__a21o_2
XFILLER_99_522 VGND VGND VPWR VPWR sky130_fd_sc_hd__fill_2
XFILLER_101_505 VGND VGND VPWR VPWR sky130_fd_sc_hd__decap_3
X_7052_ _7276_/CLK _7052_/D _6332_/Y VGND VGND VPWR VPWR _7052_/Q sky130_fd_sc_hd__dfrtp_2
X_4264_ _4264_/A _4264_/B VGND VGND VPWR VPWR _4376_/B sky130_fd_sc_hd__nor2_2
XFILLER_86_227 VGND VGND VPWR VPWR sky130_fd_sc_hd__decap_3
XFILLER_39_143 VGND VGND VPWR VPWR sky130_fd_sc_hd__decap_3
X_4195_ _7135_/Q _4267_/A2 _4352_/B1 _7167_/Q VGND VGND VPWR VPWR _4195_/X sky130_fd_sc_hd__a22o_2
XFILLER_27_316 VGND VGND VPWR VPWR sky130_fd_sc_hd__fill_2
XFILLER_55_647 VGND VGND VPWR VPWR sky130_fd_sc_hd__fill_1
XFILLER_94_293 VGND VGND VPWR VPWR sky130_fd_sc_hd__decap_3
XFILLER_70_628 VGND VGND VPWR VPWR sky130_fd_sc_hd__decap_3
XFILLER_82_466 VGND VGND VPWR VPWR sky130_fd_sc_hd__decap_3
XFILLER_82_477 VGND VGND VPWR VPWR sky130_fd_sc_hd__decap_3
X_6905_ _6968_/CLK _6905_/D VGND VGND VPWR VPWR _6905_/Q sky130_fd_sc_hd__dfxtp_2
XFILLER_35_382 VGND VGND VPWR VPWR sky130_fd_sc_hd__decap_3
XTAP_TAPCELL_ROW_53_848 VGND VPWR sky130_fd_sc_hd__tapvpwrvgnd_1
XTAP_TAPCELL_ROW_25_517 VGND VPWR sky130_fd_sc_hd__tapvpwrvgnd_1
XFILLER_23_555 VGND VGND VPWR VPWR sky130_fd_sc_hd__decap_3
XFILLER_35_393 VGND VGND VPWR VPWR sky130_fd_sc_hd__decap_3
XFILLER_62_190 VGND VGND VPWR VPWR sky130_fd_sc_hd__decap_3
X_6836_ _6963_/CLK _6836_/D VGND VGND VPWR VPWR _6836_/Q sky130_fd_sc_hd__dfxtp_2
XFILLER_50_374 VGND VGND VPWR VPWR sky130_fd_sc_hd__fill_1
X_6767_ clkload5/A _6767_/D VGND VGND VPWR VPWR _6767_/Q sky130_fd_sc_hd__dfxtp_2
XTAP_TAPCELL_ROW_81_1169 VGND VPWR sky130_fd_sc_hd__tapvpwrvgnd_1
XFILLER_10_227 VGND VGND VPWR VPWR sky130_fd_sc_hd__decap_3
X_3979_ _7351_/Q _4520_/A0 _3989_/S VGND VGND VPWR VPWR _7351_/D sky130_fd_sc_hd__mux2_2
XFILLER_6_209 VGND VGND VPWR VPWR sky130_fd_sc_hd__decap_3
X_6698_ clkload8/A _6698_/D VGND VGND VPWR VPWR _6698_/Q sky130_fd_sc_hd__dfxtp_2
XFILLER_108_137 VGND VGND VPWR VPWR sky130_fd_sc_hd__decap_3
X_5649_ _5649_/A VGND VGND VPWR VPWR _5649_/X sky130_fd_sc_hd__buf_1
XFILLER_6_6 VGND VGND VPWR VPWR sky130_fd_sc_hd__fill_2
X_7319_ _7355_/CLK _7319_/D _6599_/Y VGND VGND VPWR VPWR _7319_/Q sky130_fd_sc_hd__dfrtp_2
XFILLER_77_205 VGND VGND VPWR VPWR sky130_fd_sc_hd__decap_3
XTAP_TAPCELL_ROW_92_1287 VGND VPWR sky130_fd_sc_hd__tapvpwrvgnd_1
XTAP_TAPCELL_ROW_92_1298 VGND VPWR sky130_fd_sc_hd__tapvpwrvgnd_1
XFILLER_100_571 VGND VGND VPWR VPWR sky130_fd_sc_hd__decap_3
XFILLER_46_614 VGND VGND VPWR VPWR sky130_fd_sc_hd__decap_3
XFILLER_58_474 VGND VGND VPWR VPWR sky130_fd_sc_hd__fill_2
XFILLER_73_411 VGND VGND VPWR VPWR sky130_fd_sc_hd__decap_3
XFILLER_85_271 VGND VGND VPWR VPWR sky130_fd_sc_hd__decap_3
XTAP_TAPCELL_ROW_5_297 VGND VPWR sky130_fd_sc_hd__tapvpwrvgnd_1
XFILLER_105_95 VGND VGND VPWR VPWR sky130_fd_sc_hd__fill_1
XFILLER_45_113 VGND VGND VPWR VPWR sky130_fd_sc_hd__decap_3
XFILLER_45_157 VGND VGND VPWR VPWR sky130_fd_sc_hd__decap_3
XFILLER_61_606 VGND VGND VPWR VPWR sky130_fd_sc_hd__decap_3
XFILLER_61_617 VGND VGND VPWR VPWR sky130_fd_sc_hd__decap_3
XFILLER_73_477 VGND VGND VPWR VPWR sky130_fd_sc_hd__fill_2
XFILLER_14_500 VGND VGND VPWR VPWR sky130_fd_sc_hd__fill_2
XFILLER_14_511 VGND VGND VPWR VPWR sky130_fd_sc_hd__decap_3
XFILLER_26_360 VGND VGND VPWR VPWR sky130_fd_sc_hd__fill_1
XFILLER_33_319 VGND VGND VPWR VPWR sky130_fd_sc_hd__decap_3
XFILLER_45_179 VGND VGND VPWR VPWR sky130_fd_sc_hd__decap_3
XFILLER_53_190 VGND VGND VPWR VPWR sky130_fd_sc_hd__decap_3
XFILLER_60_149 VGND VGND VPWR VPWR sky130_fd_sc_hd__decap_3
XFILLER_14_577 VGND VGND VPWR VPWR sky130_fd_sc_hd__decap_3
XTAP_TAPCELL_ROW_101_1394 VGND VPWR sky130_fd_sc_hd__tapvpwrvgnd_1
XFILLER_5_231 VGND VGND VPWR VPWR sky130_fd_sc_hd__fill_2
XFILLER_5_242 VGND VGND VPWR VPWR sky130_fd_sc_hd__decap_3
XFILLER_5_275 VGND VGND VPWR VPWR sky130_fd_sc_hd__decap_3
XFILLER_68_227 VGND VGND VPWR VPWR sky130_fd_sc_hd__decap_3
XFILLER_83_208 VGND VGND VPWR VPWR sky130_fd_sc_hd__decap_3
XFILLER_36_113 VGND VGND VPWR VPWR sky130_fd_sc_hd__decap_3
XFILLER_37_647 VGND VGND VPWR VPWR sky130_fd_sc_hd__fill_1
XFILLER_36_168 VGND VGND VPWR VPWR sky130_fd_sc_hd__decap_3
XFILLER_64_477 VGND VGND VPWR VPWR sky130_fd_sc_hd__fill_2
XFILLER_91_252 VGND VGND VPWR VPWR sky130_fd_sc_hd__decap_3
XFILLER_52_639 VGND VGND VPWR VPWR sky130_fd_sc_hd__decap_3
XFILLER_64_488 VGND VGND VPWR VPWR sky130_fd_sc_hd__decap_3
X_4951_ _4949_/Y _4950_/Y _4918_/B VGND VGND VPWR VPWR _4951_/Y sky130_fd_sc_hd__a21oi_2
XFILLER_17_393 VGND VGND VPWR VPWR sky130_fd_sc_hd__decap_3
XFILLER_32_341 VGND VGND VPWR VPWR sky130_fd_sc_hd__fill_2
X_4882_ _4882_/A _4882_/B VGND VGND VPWR VPWR _6998_/D sky130_fd_sc_hd__and2_2
X_3902_ _6918_/Q _3926_/A2 _3925_/B1 _6870_/Q VGND VGND VPWR VPWR _3902_/X sky130_fd_sc_hd__a22o_2
XTAP_TAPCELL_ROW_50_807 VGND VPWR sky130_fd_sc_hd__tapvpwrvgnd_1
XFILLER_20_514 VGND VGND VPWR VPWR sky130_fd_sc_hd__decap_3
X_6621_ _6622_/A VGND VGND VPWR VPWR _6621_/Y sky130_fd_sc_hd__inv_2
X_3833_ _3833_/A0 _3832_/X _3864_/S VGND VGND VPWR VPWR _7388_/D sky130_fd_sc_hd__mux2_2
XFILLER_20_558 VGND VGND VPWR VPWR sky130_fd_sc_hd__fill_1
X_6552_ _6552_/A VGND VGND VPWR VPWR _6552_/Y sky130_fd_sc_hd__inv_2
X_3764_ _6706_/Q _6796_/Q _6884_/Q _6932_/Q _3991_/B _3665_/B VGND VGND VPWR VPWR
+ _3764_/X sky130_fd_sc_hd__mux4_2
XFILLER_9_570 VGND VGND VPWR VPWR sky130_fd_sc_hd__decap_3
X_6483_ _6650_/A VGND VGND VPWR VPWR _6483_/Y sky130_fd_sc_hd__inv_2
X_3695_ _6714_/Q _3823_/A2 _3883_/B1 _6892_/Q VGND VGND VPWR VPWR _3695_/X sky130_fd_sc_hd__a22o_2
XTAP_TAPCELL_ROW_30_575 VGND VPWR sky130_fd_sc_hd__tapvpwrvgnd_1
XFILLER_105_107 VGND VGND VPWR VPWR sky130_fd_sc_hd__decap_3
XFILLER_106_619 VGND VGND VPWR VPWR sky130_fd_sc_hd__decap_3
X_7104_ _7361_/CLK _7104_/D _6384_/Y VGND VGND VPWR VPWR _7104_/Q sky130_fd_sc_hd__dfrtp_2
X_5365_ _5365_/A0 _4716_/X _5388_/S VGND VGND VPWR VPWR _7150_/D sky130_fd_sc_hd__mux2_4
X_5296_ _5296_/A0 _4716_/X _5310_/S VGND VGND VPWR VPWR _7182_/D sky130_fd_sc_hd__mux2_4
X_4316_ _7226_/Q _4349_/B1 _4341_/B1 _7130_/Q VGND VGND VPWR VPWR _4316_/X sky130_fd_sc_hd__a22o_2
XFILLER_59_249 VGND VGND VPWR VPWR sky130_fd_sc_hd__fill_2
XFILLER_87_558 VGND VGND VPWR VPWR sky130_fd_sc_hd__fill_2
X_7035_ _7380_/CLK _7035_/D _6315_/Y VGND VGND VPWR VPWR _7035_/Q sky130_fd_sc_hd__dfrtp_2
X_4247_ _7261_/Q _4260_/A2 _3966_/S _7325_/Q _4246_/X VGND VGND VPWR VPWR _4248_/C
+ sky130_fd_sc_hd__a221o_2
XTAP_TAPCELL_ROW_58_907 VGND VPWR sky130_fd_sc_hd__tapvpwrvgnd_1
XFILLER_28_625 VGND VGND VPWR VPWR sky130_fd_sc_hd__decap_3
XFILLER_74_219 VGND VGND VPWR VPWR sky130_fd_sc_hd__decap_3
X_4178_ _7264_/Q _4260_/A2 _4177_/X VGND VGND VPWR VPWR _4178_/Y sky130_fd_sc_hd__a21oi_2
XPHY_EDGE_ROW_98_Left_207 VGND VGND VPWR VPWR sky130_fd_sc_hd__decap_3
XFILLER_27_113 VGND VGND VPWR VPWR sky130_fd_sc_hd__fill_1
XFILLER_55_444 VGND VGND VPWR VPWR sky130_fd_sc_hd__fill_1
XTAP_TAPCELL_ROW_2_256 VGND VPWR sky130_fd_sc_hd__tapvpwrvgnd_1
XFILLER_55_455 VGND VGND VPWR VPWR sky130_fd_sc_hd__decap_3
XFILLER_55_477 VGND VGND VPWR VPWR sky130_fd_sc_hd__decap_3
XFILLER_82_230 VGND VGND VPWR VPWR sky130_fd_sc_hd__decap_3
XTAP_TAPCELL_ROW_66_995 VGND VPWR sky130_fd_sc_hd__tapvpwrvgnd_1
XTAP_TAPCELL_ROW_38_675 VGND VPWR sky130_fd_sc_hd__tapvpwrvgnd_1
XFILLER_42_138 VGND VGND VPWR VPWR sky130_fd_sc_hd__fill_2
XFILLER_70_458 VGND VGND VPWR VPWR sky130_fd_sc_hd__decap_3
X_6819_ _6966_/CLK _6819_/D VGND VGND VPWR VPWR _6819_/Q sky130_fd_sc_hd__dfxtp_2
XFILLER_23_396 VGND VGND VPWR VPWR sky130_fd_sc_hd__decap_3
XFILLER_50_182 VGND VGND VPWR VPWR sky130_fd_sc_hd__decap_3
XFILLER_51_24 VGND VGND VPWR VPWR sky130_fd_sc_hd__decap_3
XFILLER_51_57 VGND VGND VPWR VPWR sky130_fd_sc_hd__fill_1
XTAP_TAPCELL_ROW_94_1316 VGND VPWR sky130_fd_sc_hd__tapvpwrvgnd_1
XFILLER_2_212 VGND VGND VPWR VPWR sky130_fd_sc_hd__decap_3
XFILLER_2_223 VGND VGND VPWR VPWR sky130_fd_sc_hd__decap_3
XFILLER_2_245 VGND VGND VPWR VPWR sky130_fd_sc_hd__decap_3
XFILLER_2_256 VGND VGND VPWR VPWR sky130_fd_sc_hd__decap_3
XFILLER_104_162 VGND VGND VPWR VPWR sky130_fd_sc_hd__decap_3
XFILLER_104_195 VGND VGND VPWR VPWR sky130_fd_sc_hd__fill_1
XFILLER_76_32 VGND VGND VPWR VPWR sky130_fd_sc_hd__decap_3
XFILLER_19_603 VGND VGND VPWR VPWR sky130_fd_sc_hd__decap_3
XFILLER_65_208 VGND VGND VPWR VPWR sky130_fd_sc_hd__decap_3
XFILLER_93_528 VGND VGND VPWR VPWR sky130_fd_sc_hd__decap_3
XFILLER_19_647 VGND VGND VPWR VPWR sky130_fd_sc_hd__fill_1
XFILLER_18_135 VGND VGND VPWR VPWR sky130_fd_sc_hd__decap_3
XFILLER_18_168 VGND VGND VPWR VPWR sky130_fd_sc_hd__decap_3
XFILLER_34_617 VGND VGND VPWR VPWR sky130_fd_sc_hd__decap_3
XFILLER_33_116 VGND VGND VPWR VPWR sky130_fd_sc_hd__decap_3
XFILLER_46_499 VGND VGND VPWR VPWR sky130_fd_sc_hd__decap_3
XFILLER_92_53 VGND VGND VPWR VPWR sky130_fd_sc_hd__decap_3
XFILLER_61_447 VGND VGND VPWR VPWR sky130_fd_sc_hd__fill_1
XFILLER_92_75 VGND VGND VPWR VPWR sky130_fd_sc_hd__fill_1
XTAP_TAPCELL_ROW_103_1423 VGND VPWR sky130_fd_sc_hd__tapvpwrvgnd_1
XFILLER_14_396 VGND VGND VPWR VPWR sky130_fd_sc_hd__decap_3
XFILLER_10_580 VGND VGND VPWR VPWR sky130_fd_sc_hd__decap_3
X_3480_ _7088_/Q _4335_/B1 _4351_/B1 _7120_/Q VGND VGND VPWR VPWR _3482_/B sky130_fd_sc_hd__a22o_2
XFILLER_6_584 VGND VGND VPWR VPWR sky130_fd_sc_hd__decap_3
XFILLER_6_595 VGND VGND VPWR VPWR sky130_fd_sc_hd__decap_3
XFILLER_37_3 VGND VGND VPWR VPWR sky130_fd_sc_hd__fill_1
XFILLER_69_503 VGND VGND VPWR VPWR sky130_fd_sc_hd__fill_1
XFILLER_69_536 VGND VGND VPWR VPWR sky130_fd_sc_hd__decap_3
X_5150_ _3501_/X _3618_/X _5145_/X _5149_/Y VGND VGND VPWR VPWR _5659_/B sky130_fd_sc_hd__a31o_2
X_4101_ _7141_/Q _4428_/B1 _4100_/X VGND VGND VPWR VPWR _4141_/A sky130_fd_sc_hd__a21oi_2
XFILLER_84_528 VGND VGND VPWR VPWR sky130_fd_sc_hd__decap_3
X_4032_ _7246_/Q _4414_/A2 _3939_/S _7214_/Q VGND VGND VPWR VPWR _4032_/X sky130_fd_sc_hd__a22o_2
XFILLER_25_606 VGND VGND VPWR VPWR sky130_fd_sc_hd__decap_3
XFILLER_92_550 VGND VGND VPWR VPWR sky130_fd_sc_hd__decap_3
XTAP_TAPCELL_ROW_69_1031 VGND VPWR sky130_fd_sc_hd__tapvpwrvgnd_1
XFILLER_25_617 VGND VGND VPWR VPWR sky130_fd_sc_hd__decap_3
XFILLER_37_477 VGND VGND VPWR VPWR sky130_fd_sc_hd__decap_3
XFILLER_92_583 VGND VGND VPWR VPWR sky130_fd_sc_hd__decap_3
XFILLER_40_609 VGND VGND VPWR VPWR sky130_fd_sc_hd__decap_3
XTAP_TAPCELL_ROW_63_954 VGND VPWR sky130_fd_sc_hd__tapvpwrvgnd_1
XTAP_TAPCELL_ROW_35_634 VGND VPWR sky130_fd_sc_hd__tapvpwrvgnd_1
XFILLER_32_193 VGND VGND VPWR VPWR sky130_fd_sc_hd__decap_3
X_4865_ _4865_/A0 _4864_/X _4865_/S VGND VGND VPWR VPWR _7270_/D sky130_fd_sc_hd__mux2_2
XFILLER_20_355 VGND VGND VPWR VPWR sky130_fd_sc_hd__decap_3
X_6604_ _6638_/A VGND VGND VPWR VPWR _6604_/Y sky130_fd_sc_hd__inv_2
X_4796_ _4447_/A _4779_/X _4447_/B _4780_/Y _4814_/A VGND VGND VPWR VPWR _4796_/Y
+ sky130_fd_sc_hd__a311oi_2
X_3816_ _6792_/Q _3913_/A2 _3911_/B1 _6880_/Q _3815_/X VGND VGND VPWR VPWR _3816_/X
+ sky130_fd_sc_hd__a221o_2
XFILLER_20_388 VGND VGND VPWR VPWR sky130_fd_sc_hd__decap_3
X_6535_ _6536_/A VGND VGND VPWR VPWR _6535_/Y sky130_fd_sc_hd__inv_2
X_3747_ _3741_/X _3743_/X _3745_/X _3746_/X VGND VGND VPWR VPWR _3747_/X sky130_fd_sc_hd__a22o_2
XFILLER_106_416 VGND VGND VPWR VPWR sky130_fd_sc_hd__decap_3
XFILLER_106_427 VGND VGND VPWR VPWR sky130_fd_sc_hd__decap_3
X_6466_ _6592_/A VGND VGND VPWR VPWR _6466_/Y sky130_fd_sc_hd__inv_2
X_6397_ _6397_/A VGND VGND VPWR VPWR _6397_/Y sky130_fd_sc_hd__inv_2
X_5417_ _5417_/A0 _5125_/Y _5429_/S VGND VGND VPWR VPWR _7125_/D sky130_fd_sc_hd__mux2_2
XFILLER_87_311 VGND VGND VPWR VPWR sky130_fd_sc_hd__decap_3
X_5348_ _7157_/Q _5125_/Y _7412_/A VGND VGND VPWR VPWR _7157_/D sky130_fd_sc_hd__mux2_2
XTAP_TAPCELL_ROW_7_315 VGND VPWR sky130_fd_sc_hd__tapvpwrvgnd_1
XFILLER_102_633 VGND VGND VPWR VPWR sky130_fd_sc_hd__decap_3
XFILLER_87_388 VGND VGND VPWR VPWR sky130_fd_sc_hd__decap_3
X_7018_ _7362_/CLK _7018_/D _6298_/Y VGND VGND VPWR VPWR _7018_/Q sky130_fd_sc_hd__dfrtp_2
XFILLER_87_399 VGND VGND VPWR VPWR sky130_fd_sc_hd__decap_3
XFILLER_28_455 VGND VGND VPWR VPWR sky130_fd_sc_hd__decap_3
XFILLER_46_35 VGND VGND VPWR VPWR sky130_fd_sc_hd__decap_3
XFILLER_16_628 VGND VGND VPWR VPWR sky130_fd_sc_hd__decap_3
XFILLER_28_477 VGND VGND VPWR VPWR sky130_fd_sc_hd__decap_3
XFILLER_70_200 VGND VGND VPWR VPWR sky130_fd_sc_hd__decap_3
XFILLER_102_52 VGND VGND VPWR VPWR sky130_fd_sc_hd__decap_3
XFILLER_15_138 VGND VGND VPWR VPWR sky130_fd_sc_hd__decap_3
XFILLER_102_85 VGND VGND VPWR VPWR sky130_fd_sc_hd__decap_3
XFILLER_11_311 VGND VGND VPWR VPWR sky130_fd_sc_hd__decap_3
XFILLER_51_480 VGND VGND VPWR VPWR sky130_fd_sc_hd__decap_3
XFILLER_62_67 VGND VGND VPWR VPWR sky130_fd_sc_hd__decap_3
XFILLER_11_366 VGND VGND VPWR VPWR sky130_fd_sc_hd__decap_3
XFILLER_11_399 VGND VGND VPWR VPWR sky130_fd_sc_hd__fill_1
XFILLER_11_60 VGND VGND VPWR VPWR sky130_fd_sc_hd__decap_3
XFILLER_3_532 VGND VGND VPWR VPWR sky130_fd_sc_hd__decap_3
XFILLER_3_576 VGND VGND VPWR VPWR sky130_fd_sc_hd__decap_3
XFILLER_105_482 VGND VGND VPWR VPWR sky130_fd_sc_hd__fill_1
XFILLER_78_322 VGND VGND VPWR VPWR sky130_fd_sc_hd__fill_2
XFILLER_87_53 VGND VGND VPWR VPWR sky130_fd_sc_hd__decap_3
XFILLER_87_75 VGND VGND VPWR VPWR sky130_fd_sc_hd__fill_1
XFILLER_38_208 VGND VGND VPWR VPWR sky130_fd_sc_hd__decap_3
XFILLER_78_377 VGND VGND VPWR VPWR sky130_fd_sc_hd__decap_3
XFILLER_66_539 VGND VGND VPWR VPWR sky130_fd_sc_hd__decap_3
XFILLER_74_550 VGND VGND VPWR VPWR sky130_fd_sc_hd__decap_3
XFILLER_93_358 VGND VGND VPWR VPWR sky130_fd_sc_hd__fill_2
XFILLER_93_369 VGND VGND VPWR VPWR sky130_fd_sc_hd__fill_2
XFILLER_34_414 VGND VGND VPWR VPWR sky130_fd_sc_hd__decap_3
XFILLER_61_200 VGND VGND VPWR VPWR sky130_fd_sc_hd__fill_1
XFILLER_61_211 VGND VGND VPWR VPWR sky130_fd_sc_hd__decap_3
XFILLER_74_583 VGND VGND VPWR VPWR sky130_fd_sc_hd__decap_3
XFILLER_34_447 VGND VGND VPWR VPWR sky130_fd_sc_hd__decap_3
XFILLER_34_469 VGND VGND VPWR VPWR sky130_fd_sc_hd__decap_3
XTAP_TAPCELL_ROW_60_924 VGND VPWR sky130_fd_sc_hd__tapvpwrvgnd_1
XTAP_TAPCELL_ROW_32_604 VGND VPWR sky130_fd_sc_hd__tapvpwrvgnd_1
XFILLER_30_631 VGND VGND VPWR VPWR sky130_fd_sc_hd__decap_3
XFILLER_14_193 VGND VGND VPWR VPWR sky130_fd_sc_hd__decap_3
X_4650_ _4440_/A _4650_/B VGND VGND VPWR VPWR _4810_/B sky130_fd_sc_hd__and2b_2
X_3601_ _3427_/B _3600_/Y _3599_/A VGND VGND VPWR VPWR _4613_/B sky130_fd_sc_hd__a21oi_2
XTAP_TAPCELL_ROW_12_372 VGND VPWR sky130_fd_sc_hd__tapvpwrvgnd_1
X_6320_ _6669_/A VGND VGND VPWR VPWR _6320_/Y sky130_fd_sc_hd__inv_2
X_4581_ _4581_/A _4589_/B VGND VGND VPWR VPWR _7290_/D sky130_fd_sc_hd__and2_2
XTAP_TAPCELL_ROW_40_692 VGND VPWR sky130_fd_sc_hd__tapvpwrvgnd_1
Xhold805 _6797_/Q VGND VGND VPWR VPWR _6797_/D sky130_fd_sc_hd__dlygate4sd3_1
Xhold816 _6756_/Q VGND VGND VPWR VPWR _6756_/D sky130_fd_sc_hd__dlygate4sd3_1
Xhold827 _6939_/Q VGND VGND VPWR VPWR _6939_/D sky130_fd_sc_hd__dlygate4sd3_1
X_3532_ _5135_/A1 _3509_/Y _5642_/B _5659_/A _4471_/S VGND VGND VPWR VPWR _3621_/A
+ sky130_fd_sc_hd__a41o_2
Xhold838 _6806_/Q VGND VGND VPWR VPWR _6806_/D sky130_fd_sc_hd__dlygate4sd3_1
Xhold849 _7116_/Q VGND VGND VPWR VPWR _7116_/D sky130_fd_sc_hd__dlygate4sd3_1
Xmax_cap568 _6611_/A VGND VGND VPWR VPWR _6613_/A sky130_fd_sc_hd__buf_2
Xmax_cap557 _4994_/A2 VGND VGND VPWR VPWR _4275_/A sky130_fd_sc_hd__clkdlybuf4s25_1
X_3463_ _7057_/Q _3558_/B _3429_/X _3462_/X VGND VGND VPWR VPWR _3545_/A sky130_fd_sc_hd__o211ai_4
XFILLER_103_408 VGND VGND VPWR VPWR sky130_fd_sc_hd__decap_3
X_3394_ _3394_/A _3429_/B VGND VGND VPWR VPWR _3558_/B sky130_fd_sc_hd__or2_2
XFILLER_97_631 VGND VGND VPWR VPWR sky130_fd_sc_hd__decap_3
XFILLER_29_208 VGND VGND VPWR VPWR sky130_fd_sc_hd__decap_3
XFILLER_96_152 VGND VGND VPWR VPWR sky130_fd_sc_hd__decap_3
XFILLER_69_399 VGND VGND VPWR VPWR sky130_fd_sc_hd__decap_3
XFILLER_84_336 VGND VGND VPWR VPWR sky130_fd_sc_hd__decap_3
XFILLER_96_185 VGND VGND VPWR VPWR sky130_fd_sc_hd__decap_3
XFILLER_72_509 VGND VGND VPWR VPWR sky130_fd_sc_hd__fill_1
XTAP_TAPCELL_ROW_48_781 VGND VPWR sky130_fd_sc_hd__tapvpwrvgnd_1
XFILLER_25_436 VGND VGND VPWR VPWR sky130_fd_sc_hd__decap_3
XFILLER_25_458 VGND VGND VPWR VPWR sky130_fd_sc_hd__decap_3
XFILLER_52_222 VGND VGND VPWR VPWR sky130_fd_sc_hd__decap_3
XFILLER_52_244 VGND VGND VPWR VPWR sky130_fd_sc_hd__fill_1
XFILLER_80_542 VGND VGND VPWR VPWR sky130_fd_sc_hd__decap_3
XFILLER_92_380 VGND VGND VPWR VPWR sky130_fd_sc_hd__fill_1
XTAP_TAPCELL_ROW_48_792 VGND VPWR sky130_fd_sc_hd__tapvpwrvgnd_1
XFILLER_13_609 VGND VGND VPWR VPWR sky130_fd_sc_hd__decap_3
XFILLER_52_277 VGND VGND VPWR VPWR sky130_fd_sc_hd__fill_1
XFILLER_21_620 VGND VGND VPWR VPWR sky130_fd_sc_hd__decap_3
X_4917_ _4967_/A _4950_/A _4967_/B VGND VGND VPWR VPWR _4918_/B sky130_fd_sc_hd__and3_2
XFILLER_20_141 VGND VGND VPWR VPWR sky130_fd_sc_hd__decap_3
X_4848_ _4884_/A _4904_/B _4140_/X VGND VGND VPWR VPWR _4872_/B sky130_fd_sc_hd__o21ba_2
XFILLER_20_174 VGND VGND VPWR VPWR sky130_fd_sc_hd__decap_3
X_4779_ _4779_/A _4827_/B VGND VGND VPWR VPWR _4779_/X sky130_fd_sc_hd__or2_2
X_6518_ _6618_/A VGND VGND VPWR VPWR _6518_/Y sky130_fd_sc_hd__inv_2
X_6449_ _6614_/A VGND VGND VPWR VPWR _6449_/Y sky130_fd_sc_hd__inv_2
XFILLER_0_513 VGND VGND VPWR VPWR sky130_fd_sc_hd__decap_3
XFILLER_88_620 VGND VGND VPWR VPWR sky130_fd_sc_hd__decap_3
XFILLER_0_557 VGND VGND VPWR VPWR sky130_fd_sc_hd__decap_3
XFILLER_102_463 VGND VGND VPWR VPWR sky130_fd_sc_hd__decap_3
XFILLER_48_506 VGND VGND VPWR VPWR sky130_fd_sc_hd__fill_1
XFILLER_57_12 VGND VGND VPWR VPWR sky130_fd_sc_hd__decap_3
XFILLER_57_34 VGND VGND VPWR VPWR sky130_fd_sc_hd__decap_3
XFILLER_87_152 VGND VGND VPWR VPWR sky130_fd_sc_hd__decap_3
XFILLER_102_496 VGND VGND VPWR VPWR sky130_fd_sc_hd__decap_3
XFILLER_48_539 VGND VGND VPWR VPWR sky130_fd_sc_hd__decap_3
XFILLER_75_325 VGND VGND VPWR VPWR sky130_fd_sc_hd__decap_3
XTAP_TAPCELL_ROW_89_1259 VGND VPWR sky130_fd_sc_hd__tapvpwrvgnd_1
XFILLER_16_414 VGND VGND VPWR VPWR sky130_fd_sc_hd__decap_3
XFILLER_43_200 VGND VGND VPWR VPWR sky130_fd_sc_hd__decap_3
XFILLER_90_339 VGND VGND VPWR VPWR sky130_fd_sc_hd__decap_3
XFILLER_28_285 VGND VGND VPWR VPWR sky130_fd_sc_hd__fill_1
XFILLER_73_55 VGND VGND VPWR VPWR sky130_fd_sc_hd__fill_1
XFILLER_83_391 VGND VGND VPWR VPWR sky130_fd_sc_hd__fill_1
XFILLER_31_406 VGND VGND VPWR VPWR sky130_fd_sc_hd__decap_3
XFILLER_43_244 VGND VGND VPWR VPWR sky130_fd_sc_hd__decap_3
XFILLER_71_553 VGND VGND VPWR VPWR sky130_fd_sc_hd__decap_3
XFILLER_71_564 VGND VGND VPWR VPWR sky130_fd_sc_hd__decap_3
XFILLER_12_631 VGND VGND VPWR VPWR sky130_fd_sc_hd__decap_3
XFILLER_24_480 VGND VGND VPWR VPWR sky130_fd_sc_hd__decap_3
XFILLER_11_141 VGND VGND VPWR VPWR sky130_fd_sc_hd__decap_3
XFILLER_8_613 VGND VGND VPWR VPWR sky130_fd_sc_hd__decap_3
XFILLER_22_81 VGND VGND VPWR VPWR sky130_fd_sc_hd__decap_3
XFILLER_7_167 VGND VGND VPWR VPWR sky130_fd_sc_hd__fill_1
XFILLER_7_178 VGND VGND VPWR VPWR sky130_fd_sc_hd__decap_3
XFILLER_3_340 VGND VGND VPWR VPWR sky130_fd_sc_hd__decap_3
XFILLER_3_384 VGND VGND VPWR VPWR sky130_fd_sc_hd__decap_3
XFILLER_79_642 VGND VGND VPWR VPWR sky130_fd_sc_hd__decap_3
XFILLER_105_290 VGND VGND VPWR VPWR sky130_fd_sc_hd__decap_3
XFILLER_66_303 VGND VGND VPWR VPWR sky130_fd_sc_hd__decap_3
XFILLER_78_141 VGND VGND VPWR VPWR sky130_fd_sc_hd__decap_3
XFILLER_66_336 VGND VGND VPWR VPWR sky130_fd_sc_hd__decap_3
XFILLER_93_111 VGND VGND VPWR VPWR sky130_fd_sc_hd__fill_1
XFILLER_94_645 VGND VGND VPWR VPWR sky130_fd_sc_hd__decap_3
XFILLER_47_550 VGND VGND VPWR VPWR sky130_fd_sc_hd__decap_3
XFILLER_66_347 VGND VGND VPWR VPWR sky130_fd_sc_hd__decap_3
XFILLER_93_144 VGND VGND VPWR VPWR sky130_fd_sc_hd__decap_3
XFILLER_93_155 VGND VGND VPWR VPWR sky130_fd_sc_hd__decap_3
XFILLER_19_274 VGND VGND VPWR VPWR sky130_fd_sc_hd__decap_3
XFILLER_47_561 VGND VGND VPWR VPWR sky130_fd_sc_hd__decap_3
XFILLER_34_233 VGND VGND VPWR VPWR sky130_fd_sc_hd__decap_3
XFILLER_62_531 VGND VGND VPWR VPWR sky130_fd_sc_hd__fill_1
XFILLER_34_266 VGND VGND VPWR VPWR sky130_fd_sc_hd__fill_2
XTAP_TAPCELL_ROW_45_751 VGND VPWR sky130_fd_sc_hd__tapvpwrvgnd_1
XTAP_TAPCELL_ROW_17_431 VGND VPWR sky130_fd_sc_hd__tapvpwrvgnd_1
XFILLER_22_439 VGND VGND VPWR VPWR sky130_fd_sc_hd__fill_2
XFILLER_34_299 VGND VGND VPWR VPWR sky130_fd_sc_hd__decap_3
X_4702_ _6991_/Q _5026_/A VGND VGND VPWR VPWR _5001_/A sky130_fd_sc_hd__and2_2
XFILLER_30_483 VGND VGND VPWR VPWR sky130_fd_sc_hd__decap_3
X_5682_ _5682_/A0 _6691_/Q _5708_/S VGND VGND VPWR VPWR _6691_/D sky130_fd_sc_hd__mux2_2
X_4633_ _4633_/A _4903_/A _4845_/A _4890_/B VGND VGND VPWR VPWR _4633_/X sky130_fd_sc_hd__or4_2
X_7352_ _7352_/CLK _7352_/D _6632_/Y VGND VGND VPWR VPWR _7352_/Q sky130_fd_sc_hd__dfrtp_2
Xhold602 _6837_/Q VGND VGND VPWR VPWR _6837_/D sky130_fd_sc_hd__dlygate4sd3_1
X_7283_ _7348_/CLK _7283_/D _6563_/Y VGND VGND VPWR VPWR _7283_/Q sky130_fd_sc_hd__dfrtp_2
Xhold613 _6848_/Q VGND VGND VPWR VPWR _6848_/D sky130_fd_sc_hd__dlygate4sd3_1
Xhold624 _6834_/Q VGND VGND VPWR VPWR _6834_/D sky130_fd_sc_hd__dlygate4sd3_1
Xhold635 _6782_/Q VGND VGND VPWR VPWR _6782_/D sky130_fd_sc_hd__dlygate4sd3_1
X_6303_ _6622_/A VGND VGND VPWR VPWR _6303_/Y sky130_fd_sc_hd__inv_2
X_3515_ _3509_/Y _3510_/X _4285_/B1 VGND VGND VPWR VPWR _4938_/A sky130_fd_sc_hd__a21o_2
XFILLER_103_216 VGND VGND VPWR VPWR sky130_fd_sc_hd__decap_3
Xhold646 _6881_/Q VGND VGND VPWR VPWR _6881_/D sky130_fd_sc_hd__dlygate4sd3_1
Xhold657 _6752_/Q VGND VGND VPWR VPWR _6752_/D sky130_fd_sc_hd__dlygate4sd3_1
Xhold668 _6861_/Q VGND VGND VPWR VPWR _6861_/D sky130_fd_sc_hd__dlygate4sd3_1
Xhold679 _6820_/Q VGND VGND VPWR VPWR _6820_/D sky130_fd_sc_hd__dlygate4sd3_1
X_4495_ _4495_/A0 _7300_/Q _4495_/S VGND VGND VPWR VPWR _7332_/D sky130_fd_sc_hd__mux2_2
XFILLER_85_601 VGND VGND VPWR VPWR sky130_fd_sc_hd__decap_3
X_3377_ _3394_/A _3429_/A _5641_/A _5161_/A VGND VGND VPWR VPWR _3377_/X sky130_fd_sc_hd__and4bb_4
XFILLER_69_185 VGND VGND VPWR VPWR sky130_fd_sc_hd__decap_3
XFILLER_85_623 VGND VGND VPWR VPWR sky130_fd_sc_hd__fill_1
X_5116_ _5110_/Y _5111_/X _5115_/X VGND VGND VPWR VPWR _5116_/Y sky130_fd_sc_hd__o21ai_2
XFILLER_84_122 VGND VGND VPWR VPWR sky130_fd_sc_hd__fill_2
XFILLER_84_144 VGND VGND VPWR VPWR sky130_fd_sc_hd__decap_3
X_5047_ _5114_/B _4617_/B _4617_/C _5100_/A VGND VGND VPWR VPWR _5047_/Y sky130_fd_sc_hd__o31ai_1
XFILLER_38_561 VGND VGND VPWR VPWR sky130_fd_sc_hd__fill_2
XFILLER_38_572 VGND VGND VPWR VPWR sky130_fd_sc_hd__decap_3
XFILLER_84_166 VGND VGND VPWR VPWR sky130_fd_sc_hd__decap_3
XFILLER_25_211 VGND VGND VPWR VPWR sky130_fd_sc_hd__decap_3
XFILLER_65_391 VGND VGND VPWR VPWR sky130_fd_sc_hd__fill_1
XFILLER_80_361 VGND VGND VPWR VPWR sky130_fd_sc_hd__decap_3
X_6998_ _7406_/CLK _6998_/D _6278_/Y VGND VGND VPWR VPWR _6998_/Q sky130_fd_sc_hd__dfrtp_2
XFILLER_13_428 VGND VGND VPWR VPWR sky130_fd_sc_hd__decap_3
XFILLER_25_277 VGND VGND VPWR VPWR sky130_fd_sc_hd__decap_3
XFILLER_25_299 VGND VGND VPWR VPWR sky130_fd_sc_hd__fill_2
XFILLER_40_203 VGND VGND VPWR VPWR sky130_fd_sc_hd__decap_3
XFILLER_53_586 VGND VGND VPWR VPWR sky130_fd_sc_hd__decap_3
XFILLER_80_372 VGND VGND VPWR VPWR sky130_fd_sc_hd__decap_3
XFILLER_43_69 VGND VGND VPWR VPWR sky130_fd_sc_hd__fill_2
XFILLER_21_461 VGND VGND VPWR VPWR sky130_fd_sc_hd__decap_3
XPHY_EDGE_ROW_80_Left_189 VGND VGND VPWR VPWR sky130_fd_sc_hd__decap_3
XFILLER_107_511 VGND VGND VPWR VPWR sky130_fd_sc_hd__decap_3
XFILLER_5_638 VGND VGND VPWR VPWR sky130_fd_sc_hd__decap_3
XFILLER_68_77 VGND VGND VPWR VPWR sky130_fd_sc_hd__decap_3
XFILLER_0_365 VGND VGND VPWR VPWR sky130_fd_sc_hd__decap_3
XFILLER_68_88 VGND VGND VPWR VPWR sky130_fd_sc_hd__decap_3
XFILLER_75_111 VGND VGND VPWR VPWR sky130_fd_sc_hd__fill_1
XFILLER_102_293 VGND VGND VPWR VPWR sky130_fd_sc_hd__decap_3
XFILLER_36_509 VGND VGND VPWR VPWR sky130_fd_sc_hd__decap_3
XFILLER_48_347 VGND VGND VPWR VPWR sky130_fd_sc_hd__decap_3
XFILLER_48_358 VGND VGND VPWR VPWR sky130_fd_sc_hd__decap_3
XFILLER_76_645 VGND VGND VPWR VPWR sky130_fd_sc_hd__decap_3
XFILLER_29_561 VGND VGND VPWR VPWR sky130_fd_sc_hd__decap_3
XFILLER_29_572 VGND VGND VPWR VPWR sky130_fd_sc_hd__decap_3
XFILLER_63_317 VGND VGND VPWR VPWR sky130_fd_sc_hd__decap_3
XFILLER_16_222 VGND VGND VPWR VPWR sky130_fd_sc_hd__decap_3
XFILLER_75_199 VGND VGND VPWR VPWR sky130_fd_sc_hd__decap_3
Xplace328 _5708_/S VGND VGND VPWR VPWR _5697_/S sky130_fd_sc_hd__buf_2
Xplace317 _3424_/S VGND VGND VPWR VPWR _4327_/A sky130_fd_sc_hd__buf_2
Xplace306 _3618_/X VGND VGND VPWR VPWR _4969_/B sky130_fd_sc_hd__buf_2
XFILLER_44_553 VGND VGND VPWR VPWR sky130_fd_sc_hd__fill_1
XFILLER_71_361 VGND VGND VPWR VPWR sky130_fd_sc_hd__decap_3
XFILLER_90_169 VGND VGND VPWR VPWR sky130_fd_sc_hd__decap_3
Xplace339 _5427_/S VGND VGND VPWR VPWR _5400_/S sky130_fd_sc_hd__buf_2
XFILLER_31_203 VGND VGND VPWR VPWR sky130_fd_sc_hd__decap_3
XTAP_TAPCELL_ROW_42_721 VGND VPWR sky130_fd_sc_hd__tapvpwrvgnd_1
XTAP_TAPCELL_ROW_14_401 VGND VPWR sky130_fd_sc_hd__tapvpwrvgnd_1
XFILLER_12_450 VGND VGND VPWR VPWR sky130_fd_sc_hd__decap_3
XFILLER_8_421 VGND VGND VPWR VPWR sky130_fd_sc_hd__decap_3
XFILLER_69_6 VGND VGND VPWR VPWR sky130_fd_sc_hd__decap_3
X_3300_ _3353_/B VGND VGND VPWR VPWR _4467_/A sky130_fd_sc_hd__inv_2
XFILLER_98_203 VGND VGND VPWR VPWR sky130_fd_sc_hd__decap_3
XFILLER_3_181 VGND VGND VPWR VPWR sky130_fd_sc_hd__decap_3
X_4280_ _7222_/Q _3377_/X _3366_/X _7158_/Q _4279_/X VGND VGND VPWR VPWR _4280_/X
+ sky130_fd_sc_hd__a221o_2
XFILLER_98_236 VGND VGND VPWR VPWR sky130_fd_sc_hd__decap_3
XFILLER_79_461 VGND VGND VPWR VPWR sky130_fd_sc_hd__decap_3
XTAP_TAPCELL_ROW_72_1060 VGND VPWR sky130_fd_sc_hd__tapvpwrvgnd_1
XFILLER_67_612 VGND VGND VPWR VPWR sky130_fd_sc_hd__decap_3
XFILLER_67_634 VGND VGND VPWR VPWR sky130_fd_sc_hd__decap_3
XFILLER_79_494 VGND VGND VPWR VPWR sky130_fd_sc_hd__decap_3
XFILLER_66_144 VGND VGND VPWR VPWR sky130_fd_sc_hd__decap_3
XFILLER_54_306 VGND VGND VPWR VPWR sky130_fd_sc_hd__fill_2
XFILLER_94_486 VGND VGND VPWR VPWR sky130_fd_sc_hd__fill_2
XFILLER_47_380 VGND VGND VPWR VPWR sky130_fd_sc_hd__decap_3
XFILLER_81_147 VGND VGND VPWR VPWR sky130_fd_sc_hd__fill_2
X_6921_ clkload9/A _6921_/D VGND VGND VPWR VPWR _6921_/Q sky130_fd_sc_hd__dfxtp_2
XFILLER_35_564 VGND VGND VPWR VPWR sky130_fd_sc_hd__fill_1
XFILLER_62_350 VGND VGND VPWR VPWR sky130_fd_sc_hd__decap_3
XFILLER_81_169 VGND VGND VPWR VPWR sky130_fd_sc_hd__decap_3
X_6852_ _6966_/CLK _6852_/D VGND VGND VPWR VPWR _6852_/Q sky130_fd_sc_hd__dfxtp_2
XFILLER_22_214 VGND VGND VPWR VPWR sky130_fd_sc_hd__decap_3
XFILLER_50_523 VGND VGND VPWR VPWR sky130_fd_sc_hd__decap_3
XFILLER_62_361 VGND VGND VPWR VPWR sky130_fd_sc_hd__decap_3
Xfanout18 _6260_/A VGND VGND VPWR VPWR _6463_/A sky130_fd_sc_hd__buf_2
Xfanout29 _6559_/A VGND VGND VPWR VPWR _6624_/A sky130_fd_sc_hd__clkdlybuf4s25_1
XFILLER_50_556 VGND VGND VPWR VPWR sky130_fd_sc_hd__decap_3
X_6783_ clkload4/A _6783_/D VGND VGND VPWR VPWR _6783_/Q sky130_fd_sc_hd__dfxtp_2
XFILLER_50_589 VGND VGND VPWR VPWR sky130_fd_sc_hd__decap_3
XFILLER_30_280 VGND VGND VPWR VPWR sky130_fd_sc_hd__decap_3
X_5665_ _5665_/A _5665_/B _5665_/C _5665_/D VGND VGND VPWR VPWR _5666_/B sky130_fd_sc_hd__and4_2
X_7404_ _7405_/CLK _7404_/D _6684_/Y VGND VGND VPWR VPWR _7404_/Q sky130_fd_sc_hd__dfrtp_2
X_4616_ _3547_/A _3547_/B _4614_/X _4615_/Y VGND VGND VPWR VPWR _4617_/C sky130_fd_sc_hd__a31o_2
XTAP_TAPCELL_ROW_20_459 VGND VPWR sky130_fd_sc_hd__tapvpwrvgnd_1
X_7335_ _7405_/CLK _7335_/D _6615_/Y VGND VGND VPWR VPWR _7335_/Q sky130_fd_sc_hd__dfrtp_2
XFILLER_2_619 VGND VGND VPWR VPWR sky130_fd_sc_hd__decap_3
XFILLER_104_536 VGND VGND VPWR VPWR sky130_fd_sc_hd__decap_3
XFILLER_89_225 VGND VGND VPWR VPWR sky130_fd_sc_hd__decap_3
X_7266_ _7362_/CLK _7266_/D _6546_/Y VGND VGND VPWR VPWR _7266_/Q sky130_fd_sc_hd__dfrtp_2
X_4478_ _7340_/Q _7308_/Q _4478_/S VGND VGND VPWR VPWR _7340_/D sky130_fd_sc_hd__mux2_2
XFILLER_89_258 VGND VGND VPWR VPWR sky130_fd_sc_hd__decap_3
X_7197_ _7357_/CLK _7197_/D _6477_/Y VGND VGND VPWR VPWR _7197_/Q sky130_fd_sc_hd__dfrtp_2
X_3429_ _3429_/A _3429_/B VGND VGND VPWR VPWR _3429_/X sky130_fd_sc_hd__or2_2
XFILLER_57_111 VGND VGND VPWR VPWR sky130_fd_sc_hd__fill_1
XFILLER_58_634 VGND VGND VPWR VPWR sky130_fd_sc_hd__decap_3
XFILLER_38_58 VGND VGND VPWR VPWR sky130_fd_sc_hd__decap_3
XFILLER_58_645 VGND VGND VPWR VPWR sky130_fd_sc_hd__decap_3
Xhold1110 _7339_/Q VGND VGND VPWR VPWR _4480_/A0 sky130_fd_sc_hd__dlygate4sd3_1
Xhold1121 _7125_/Q VGND VGND VPWR VPWR _5417_/A0 sky130_fd_sc_hd__dlygate4sd3_1
Xhold1132 _7124_/Q VGND VGND VPWR VPWR _5419_/A0 sky130_fd_sc_hd__dlygate4sd3_1
XFILLER_18_509 VGND VGND VPWR VPWR sky130_fd_sc_hd__decap_3
XFILLER_73_604 VGND VGND VPWR VPWR sky130_fd_sc_hd__decap_3
XFILLER_85_486 VGND VGND VPWR VPWR sky130_fd_sc_hd__decap_3
Xhold1143 _7350_/Q VGND VGND VPWR VPWR _5688_/A0 sky130_fd_sc_hd__dlygate4sd3_1
Xhold1154 _7168_/Q VGND VGND VPWR VPWR _5325_/A0 sky130_fd_sc_hd__dlygate4sd3_1
Xhold1165 _7135_/Q VGND VGND VPWR VPWR _5396_/A0 sky130_fd_sc_hd__dlygate4sd3_1
Xhold1176 _7223_/Q VGND VGND VPWR VPWR _5211_/A sky130_fd_sc_hd__dlygate4sd3_1
XTAP_TAPCELL_ROW_86_1218 VGND VPWR sky130_fd_sc_hd__tapvpwrvgnd_1
XFILLER_26_531 VGND VGND VPWR VPWR sky130_fd_sc_hd__fill_1
XFILLER_38_391 VGND VGND VPWR VPWR sky130_fd_sc_hd__decap_3
XFILLER_72_136 VGND VGND VPWR VPWR sky130_fd_sc_hd__decap_3
Xhold1187 _7133_/Q VGND VGND VPWR VPWR _5400_/A0 sky130_fd_sc_hd__dlygate4sd3_1
Xhold1198 _7248_/Q VGND VGND VPWR VPWR _5157_/A0 sky130_fd_sc_hd__dlygate4sd3_1
XTAP_TAPCELL_ROW_86_1229 VGND VPWR sky130_fd_sc_hd__tapvpwrvgnd_1
XFILLER_54_35 VGND VGND VPWR VPWR sky130_fd_sc_hd__fill_1
XFILLER_72_158 VGND VGND VPWR VPWR sky130_fd_sc_hd__decap_3
XFILLER_72_169 VGND VGND VPWR VPWR sky130_fd_sc_hd__decap_3
XTAP_TAPCELL_ROW_56_879 VGND VPWR sky130_fd_sc_hd__tapvpwrvgnd_1
XTAP_TAPCELL_ROW_28_559 VGND VPWR sky130_fd_sc_hd__tapvpwrvgnd_1
XFILLER_13_225 VGND VGND VPWR VPWR sky130_fd_sc_hd__decap_3
XFILLER_41_501 VGND VGND VPWR VPWR sky130_fd_sc_hd__decap_3
XFILLER_53_372 VGND VGND VPWR VPWR sky130_fd_sc_hd__decap_3
XFILLER_70_67 VGND VGND VPWR VPWR sky130_fd_sc_hd__decap_3
XTAP_TAPCELL_ROW_97_1347 VGND VPWR sky130_fd_sc_hd__tapvpwrvgnd_1
XFILLER_107_396 VGND VGND VPWR VPWR sky130_fd_sc_hd__decap_3
XFILLER_49_612 VGND VGND VPWR VPWR sky130_fd_sc_hd__decap_3
XFILLER_49_623 VGND VGND VPWR VPWR sky130_fd_sc_hd__decap_3
XFILLER_95_228 VGND VGND VPWR VPWR sky130_fd_sc_hd__fill_1
XFILLER_103_591 VGND VGND VPWR VPWR sky130_fd_sc_hd__decap_3
XFILLER_48_144 VGND VGND VPWR VPWR sky130_fd_sc_hd__decap_3
XFILLER_76_453 VGND VGND VPWR VPWR sky130_fd_sc_hd__decap_3
XFILLER_64_626 VGND VGND VPWR VPWR sky130_fd_sc_hd__decap_3
XFILLER_91_434 VGND VGND VPWR VPWR sky130_fd_sc_hd__fill_2
XFILLER_63_169 VGND VGND VPWR VPWR sky130_fd_sc_hd__decap_3
XFILLER_91_467 VGND VGND VPWR VPWR sky130_fd_sc_hd__decap_3
XTAP_TAPCELL_ROW_106_1454 VGND VPWR sky130_fd_sc_hd__tapvpwrvgnd_1
XFILLER_17_597 VGND VGND VPWR VPWR sky130_fd_sc_hd__decap_3
XFILLER_32_512 VGND VGND VPWR VPWR sky130_fd_sc_hd__decap_3
XFILLER_44_372 VGND VGND VPWR VPWR sky130_fd_sc_hd__decap_3
XFILLER_71_191 VGND VGND VPWR VPWR sky130_fd_sc_hd__decap_3
XFILLER_32_589 VGND VGND VPWR VPWR sky130_fd_sc_hd__decap_3
X_3780_ _6967_/Q _3852_/A2 _3853_/A2 _6955_/Q VGND VGND VPWR VPWR _3780_/X sky130_fd_sc_hd__a22o_2
XFILLER_8_251 VGND VGND VPWR VPWR sky130_fd_sc_hd__fill_1
XFILLER_8_262 VGND VGND VPWR VPWR sky130_fd_sc_hd__decap_3
XFILLER_8_284 VGND VGND VPWR VPWR sky130_fd_sc_hd__decap_3
X_4401_ _7274_/Q _4437_/A2 _4430_/A2 _7242_/Q _4400_/X VGND VGND VPWR VPWR _4401_/X
+ sky130_fd_sc_hd__a221o_2
Xoutput526 _6995_/Q VGND VGND VPWR VPWR pc_out[18] sky130_fd_sc_hd__clkdlybuf4s25_1
Xoutput515 _5362_/C VGND VGND VPWR VPWR instruction_out[8] sky130_fd_sc_hd__clkdlybuf4s25_1
Xoutput504 place203/X VGND VGND VPWR VPWR instruction_out[25] sky130_fd_sc_hd__clkdlybuf4s25_1
X_5381_ _5381_/A0 _4864_/X _5388_/S VGND VGND VPWR VPWR _7142_/D sky130_fd_sc_hd__mux2_2
XFILLER_99_501 VGND VGND VPWR VPWR sky130_fd_sc_hd__decap_3
X_7120_ _7376_/CLK _7120_/D _6400_/Y VGND VGND VPWR VPWR _7120_/Q sky130_fd_sc_hd__dfrtp_2
Xoutput548 _6986_/Q VGND VGND VPWR VPWR pc_out[9] sky130_fd_sc_hd__clkdlybuf4s25_1
Xoutput537 _7005_/Q VGND VGND VPWR VPWR pc_out[28] sky130_fd_sc_hd__clkdlybuf4s25_1
X_4332_ _7191_/Q _3966_/S _3380_/Y _7383_/Q _4331_/X VGND VGND VPWR VPWR _4332_/X
+ sky130_fd_sc_hd__a221o_2
XFILLER_99_545 VGND VGND VPWR VPWR sky130_fd_sc_hd__decap_3
X_7051_ _7372_/CLK _7051_/D _6331_/Y VGND VGND VPWR VPWR _7051_/Q sky130_fd_sc_hd__dfrtp_2
X_4263_ _7134_/Q _4420_/B1 _4261_/X _4262_/X VGND VGND VPWR VPWR _4264_/B sky130_fd_sc_hd__a211o_2
XFILLER_101_517 VGND VGND VPWR VPWR sky130_fd_sc_hd__decap_3
XFILLER_39_122 VGND VGND VPWR VPWR sky130_fd_sc_hd__decap_3
XFILLER_67_420 VGND VGND VPWR VPWR sky130_fd_sc_hd__fill_2
XFILLER_67_431 VGND VGND VPWR VPWR sky130_fd_sc_hd__decap_3
X_4194_ _7231_/Q _4433_/B _4260_/A2 _7017_/Q _4193_/X VGND VGND VPWR VPWR _4194_/X
+ sky130_fd_sc_hd__a221o_2
XFILLER_39_155 VGND VGND VPWR VPWR sky130_fd_sc_hd__decap_3
XFILLER_55_604 VGND VGND VPWR VPWR sky130_fd_sc_hd__decap_3
XFILLER_55_626 VGND VGND VPWR VPWR sky130_fd_sc_hd__decap_3
XFILLER_67_464 VGND VGND VPWR VPWR sky130_fd_sc_hd__fill_2
XFILLER_94_250 VGND VGND VPWR VPWR sky130_fd_sc_hd__fill_2
XFILLER_39_199 VGND VGND VPWR VPWR sky130_fd_sc_hd__decap_3
XFILLER_94_272 VGND VGND VPWR VPWR sky130_fd_sc_hd__fill_1
XFILLER_42_309 VGND VGND VPWR VPWR sky130_fd_sc_hd__decap_3
X_6904_ _6943_/CLK _6904_/D VGND VGND VPWR VPWR _6904_/Q sky130_fd_sc_hd__dfxtp_2
XFILLER_82_489 VGND VGND VPWR VPWR sky130_fd_sc_hd__decap_3
XTAP_TAPCELL_ROW_53_849 VGND VPWR sky130_fd_sc_hd__tapvpwrvgnd_1
XTAP_TAPCELL_ROW_25_518 VGND VPWR sky130_fd_sc_hd__tapvpwrvgnd_1
XFILLER_23_534 VGND VGND VPWR VPWR sky130_fd_sc_hd__decap_3
X_6835_ clkload6/A _6835_/D VGND VGND VPWR VPWR _6835_/Q sky130_fd_sc_hd__dfxtp_2
XFILLER_10_206 VGND VGND VPWR VPWR sky130_fd_sc_hd__decap_3
X_6766_ _6974_/CLK _6766_/D VGND VGND VPWR VPWR _6766_/Q sky130_fd_sc_hd__dfxtp_2
X_5717_ _7364_/Q hold935/X _5721_/S VGND VGND VPWR VPWR _6708_/D sky130_fd_sc_hd__mux2_2
XFILLER_108_116 VGND VGND VPWR VPWR sky130_fd_sc_hd__fill_1
X_6697_ _7071_/CLK _6697_/D VGND VGND VPWR VPWR _6697_/Q sky130_fd_sc_hd__dfxtp_2
XFILLER_108_149 VGND VGND VPWR VPWR sky130_fd_sc_hd__decap_3
X_5648_ _5648_/A _5648_/B VGND VGND VPWR VPWR _5649_/A sky130_fd_sc_hd__or2_2
X_5579_ _5579_/A0 _5045_/X _5581_/S VGND VGND VPWR VPWR _7039_/D sky130_fd_sc_hd__mux2_2
XFILLER_2_416 VGND VGND VPWR VPWR sky130_fd_sc_hd__decap_3
X_7318_ _7348_/CLK _7318_/D _6598_/Y VGND VGND VPWR VPWR _7318_/Q sky130_fd_sc_hd__dfrtp_2
XFILLER_104_333 VGND VGND VPWR VPWR sky130_fd_sc_hd__fill_2
X_7249_ _7350_/CLK _7249_/D _6529_/Y VGND VGND VPWR VPWR _7249_/Q sky130_fd_sc_hd__dfrtp_2
XFILLER_104_377 VGND VGND VPWR VPWR sky130_fd_sc_hd__decap_3
XFILLER_49_57 VGND VGND VPWR VPWR sky130_fd_sc_hd__fill_1
XFILLER_77_217 VGND VGND VPWR VPWR sky130_fd_sc_hd__decap_3
XFILLER_77_228 VGND VGND VPWR VPWR sky130_fd_sc_hd__decap_3
XTAP_TAPCELL_ROW_92_1288 VGND VPWR sky130_fd_sc_hd__tapvpwrvgnd_1
XFILLER_105_41 VGND VGND VPWR VPWR sky130_fd_sc_hd__decap_3
XFILLER_18_306 VGND VGND VPWR VPWR sky130_fd_sc_hd__fill_2
XFILLER_46_604 VGND VGND VPWR VPWR sky130_fd_sc_hd__fill_1
XFILLER_46_626 VGND VGND VPWR VPWR sky130_fd_sc_hd__decap_3
XFILLER_85_250 VGND VGND VPWR VPWR sky130_fd_sc_hd__decap_3
XFILLER_92_209 VGND VGND VPWR VPWR sky130_fd_sc_hd__decap_3
XTAP_TAPCELL_ROW_5_287 VGND VPWR sky130_fd_sc_hd__tapvpwrvgnd_1
XFILLER_100_583 VGND VGND VPWR VPWR sky130_fd_sc_hd__decap_3
XFILLER_45_125 VGND VGND VPWR VPWR sky130_fd_sc_hd__decap_3
XFILLER_73_423 VGND VGND VPWR VPWR sky130_fd_sc_hd__decap_3
XFILLER_85_294 VGND VGND VPWR VPWR sky130_fd_sc_hd__decap_3
XFILLER_61_629 VGND VGND VPWR VPWR sky130_fd_sc_hd__decap_3
XFILLER_41_320 VGND VGND VPWR VPWR sky130_fd_sc_hd__decap_3
XFILLER_60_139 VGND VGND VPWR VPWR sky130_fd_sc_hd__fill_1
XFILLER_14_589 VGND VGND VPWR VPWR sky130_fd_sc_hd__decap_3
XFILLER_14_71 VGND VGND VPWR VPWR sky130_fd_sc_hd__decap_3
XFILLER_41_397 VGND VGND VPWR VPWR sky130_fd_sc_hd__decap_3
XTAP_TAPCELL_ROW_101_1395 VGND VPWR sky130_fd_sc_hd__tapvpwrvgnd_1
XFILLER_5_254 VGND VGND VPWR VPWR sky130_fd_sc_hd__decap_3
XFILLER_5_298 VGND VGND VPWR VPWR sky130_fd_sc_hd__decap_3
XFILLER_68_206 VGND VGND VPWR VPWR sky130_fd_sc_hd__decap_3
XFILLER_49_431 VGND VGND VPWR VPWR sky130_fd_sc_hd__decap_3
XFILLER_96_559 VGND VGND VPWR VPWR sky130_fd_sc_hd__decap_3
XFILLER_96_548 VGND VGND VPWR VPWR sky130_fd_sc_hd__fill_2
XFILLER_37_604 VGND VGND VPWR VPWR sky130_fd_sc_hd__decap_3
XFILLER_39_90 VGND VGND VPWR VPWR sky130_fd_sc_hd__decap_3
XFILLER_49_464 VGND VGND VPWR VPWR sky130_fd_sc_hd__fill_1
XFILLER_64_401 VGND VGND VPWR VPWR sky130_fd_sc_hd__fill_2
XFILLER_36_103 VGND VGND VPWR VPWR sky130_fd_sc_hd__fill_2
XFILLER_37_626 VGND VGND VPWR VPWR sky130_fd_sc_hd__decap_3
XFILLER_49_486 VGND VGND VPWR VPWR sky130_fd_sc_hd__decap_3
XFILLER_24_309 VGND VGND VPWR VPWR sky130_fd_sc_hd__fill_1
XFILLER_36_136 VGND VGND VPWR VPWR sky130_fd_sc_hd__decap_3
XFILLER_36_147 VGND VGND VPWR VPWR sky130_fd_sc_hd__decap_3
XFILLER_52_618 VGND VGND VPWR VPWR sky130_fd_sc_hd__decap_3
XFILLER_91_231 VGND VGND VPWR VPWR sky130_fd_sc_hd__decap_3
XFILLER_17_361 VGND VGND VPWR VPWR sky130_fd_sc_hd__decap_3
X_4950_ _4950_/A _4950_/B VGND VGND VPWR VPWR _4950_/Y sky130_fd_sc_hd__nor2_2
XFILLER_32_320 VGND VGND VPWR VPWR sky130_fd_sc_hd__decap_3
XFILLER_51_139 VGND VGND VPWR VPWR sky130_fd_sc_hd__decap_3
X_4881_ _6998_/Q _4912_/A VGND VGND VPWR VPWR _4882_/B sky130_fd_sc_hd__or2_2
X_3901_ hold943/X _3423_/A _3900_/Y VGND VGND VPWR VPWR _7381_/D sky130_fd_sc_hd__a21bo_2
X_6620_ _6654_/A VGND VGND VPWR VPWR _6620_/Y sky130_fd_sc_hd__inv_2
X_3832_ _3728_/Y _3824_/X _3826_/X _3735_/X _3831_/X VGND VGND VPWR VPWR _3832_/X
+ sky130_fd_sc_hd__a221o_2
XTAP_TAPCELL_ROW_50_808 VGND VPWR sky130_fd_sc_hd__tapvpwrvgnd_1
X_6551_ _6556_/A VGND VGND VPWR VPWR _6551_/Y sky130_fd_sc_hd__inv_2
X_3763_ hold981/X _3857_/A2 _3762_/X VGND VGND VPWR VPWR _7395_/D sky130_fd_sc_hd__a21o_2
X_6482_ _6485_/A VGND VGND VPWR VPWR _6482_/Y sky130_fd_sc_hd__inv_2
XTAP_TAPCELL_ROW_30_576 VGND VPWR sky130_fd_sc_hd__tapvpwrvgnd_1
XFILLER_9_582 VGND VGND VPWR VPWR sky130_fd_sc_hd__decap_3
XFILLER_10_29 VGND VGND VPWR VPWR sky130_fd_sc_hd__decap_3
X_7103_ _7361_/CLK _7103_/D _6383_/Y VGND VGND VPWR VPWR _7103_/Q sky130_fd_sc_hd__dfrtp_2
X_4315_ _4315_/A _4315_/B VGND VGND VPWR VPWR _4361_/A sky130_fd_sc_hd__nand2_2
XFILLER_99_386 VGND VGND VPWR VPWR sky130_fd_sc_hd__decap_3
X_7034_ _7376_/CLK _7034_/D _6314_/Y VGND VGND VPWR VPWR _7034_/Q sky130_fd_sc_hd__dfrtp_2
X_4246_ _7229_/Q _4349_/B1 _4341_/B1 _7133_/Q VGND VGND VPWR VPWR _4246_/X sky130_fd_sc_hd__a22o_2
XFILLER_28_604 VGND VGND VPWR VPWR sky130_fd_sc_hd__decap_3
XFILLER_74_209 VGND VGND VPWR VPWR sky130_fd_sc_hd__fill_1
X_4177_ _7232_/Q _4214_/A2 _4175_/X _4176_/X VGND VGND VPWR VPWR _4177_/X sky130_fd_sc_hd__a211o_2
XFILLER_28_637 VGND VGND VPWR VPWR sky130_fd_sc_hd__decap_3
XFILLER_67_272 VGND VGND VPWR VPWR sky130_fd_sc_hd__fill_2
XFILLER_82_242 VGND VGND VPWR VPWR sky130_fd_sc_hd__decap_3
XFILLER_82_253 VGND VGND VPWR VPWR sky130_fd_sc_hd__decap_3
XTAP_TAPCELL_ROW_2_257 VGND VPWR sky130_fd_sc_hd__tapvpwrvgnd_1
XFILLER_27_169 VGND VGND VPWR VPWR sky130_fd_sc_hd__fill_1
XFILLER_43_629 VGND VGND VPWR VPWR sky130_fd_sc_hd__decap_3
XFILLER_70_404 VGND VGND VPWR VPWR sky130_fd_sc_hd__decap_3
XTAP_TAPCELL_ROW_66_996 VGND VPWR sky130_fd_sc_hd__tapvpwrvgnd_1
XTAP_TAPCELL_ROW_38_676 VGND VPWR sky130_fd_sc_hd__tapvpwrvgnd_1
XFILLER_23_331 VGND VGND VPWR VPWR sky130_fd_sc_hd__fill_2
XFILLER_50_150 VGND VGND VPWR VPWR sky130_fd_sc_hd__decap_3
X_6818_ _6974_/CLK _6818_/D VGND VGND VPWR VPWR _6818_/Q sky130_fd_sc_hd__dfxtp_2
XFILLER_50_194 VGND VGND VPWR VPWR sky130_fd_sc_hd__fill_2
XFILLER_11_559 VGND VGND VPWR VPWR sky130_fd_sc_hd__fill_1
XFILLER_51_47 VGND VGND VPWR VPWR sky130_fd_sc_hd__decap_3
XFILLER_7_519 VGND VGND VPWR VPWR sky130_fd_sc_hd__decap_3
X_6749_ _6968_/CLK _6749_/D VGND VGND VPWR VPWR _6749_/Q sky130_fd_sc_hd__dfxtp_2
XTAP_TAPCELL_ROW_94_1317 VGND VPWR sky130_fd_sc_hd__tapvpwrvgnd_1
XFILLER_105_620 VGND VGND VPWR VPWR sky130_fd_sc_hd__decap_3
XFILLER_104_141 VGND VGND VPWR VPWR sky130_fd_sc_hd__decap_3
XFILLER_104_174 VGND VGND VPWR VPWR sky130_fd_sc_hd__decap_3
XFILLER_2_279 VGND VGND VPWR VPWR sky130_fd_sc_hd__decap_3
XFILLER_19_615 VGND VGND VPWR VPWR sky130_fd_sc_hd__fill_1
XFILLER_58_250 VGND VGND VPWR VPWR sky130_fd_sc_hd__fill_2
XFILLER_18_114 VGND VGND VPWR VPWR sky130_fd_sc_hd__decap_3
XFILLER_19_626 VGND VGND VPWR VPWR sky130_fd_sc_hd__decap_3
XFILLER_46_401 VGND VGND VPWR VPWR sky130_fd_sc_hd__decap_3
XFILLER_100_391 VGND VGND VPWR VPWR sky130_fd_sc_hd__decap_3
XFILLER_18_147 VGND VGND VPWR VPWR sky130_fd_sc_hd__decap_3
XFILLER_46_445 VGND VGND VPWR VPWR sky130_fd_sc_hd__decap_3
XFILLER_46_456 VGND VGND VPWR VPWR sky130_fd_sc_hd__decap_3
XFILLER_92_21 VGND VGND VPWR VPWR sky130_fd_sc_hd__decap_3
XFILLER_33_106 VGND VGND VPWR VPWR sky130_fd_sc_hd__decap_3
XFILLER_34_629 VGND VGND VPWR VPWR sky130_fd_sc_hd__decap_3
XFILLER_61_415 VGND VGND VPWR VPWR sky130_fd_sc_hd__decap_3
XFILLER_92_32 VGND VGND VPWR VPWR sky130_fd_sc_hd__decap_3
XFILLER_14_331 VGND VGND VPWR VPWR sky130_fd_sc_hd__fill_1
XFILLER_26_180 VGND VGND VPWR VPWR sky130_fd_sc_hd__decap_3
XFILLER_33_139 VGND VGND VPWR VPWR sky130_fd_sc_hd__decap_3
XTAP_TAPCELL_ROW_103_1424 VGND VPWR sky130_fd_sc_hd__tapvpwrvgnd_1
XFILLER_14_342 VGND VGND VPWR VPWR sky130_fd_sc_hd__decap_3
XFILLER_25_81 VGND VGND VPWR VPWR sky130_fd_sc_hd__decap_3
XFILLER_14_375 VGND VGND VPWR VPWR sky130_fd_sc_hd__decap_3
XFILLER_41_161 VGND VGND VPWR VPWR sky130_fd_sc_hd__decap_3
XFILLER_41_172 VGND VGND VPWR VPWR sky130_fd_sc_hd__decap_3
XFILLER_10_592 VGND VGND VPWR VPWR sky130_fd_sc_hd__decap_3
XFILLER_6_563 VGND VGND VPWR VPWR sky130_fd_sc_hd__decap_3
XFILLER_51_6 VGND VGND VPWR VPWR sky130_fd_sc_hd__fill_1
XFILLER_108_491 VGND VGND VPWR VPWR sky130_fd_sc_hd__decap_3
XFILLER_69_548 VGND VGND VPWR VPWR sky130_fd_sc_hd__decap_3
X_5080_ _5080_/A0 _5079_/X _5159_/S VGND VGND VPWR VPWR _7257_/D sky130_fd_sc_hd__mux2_2
X_4100_ _7269_/Q _4422_/A2 _4214_/A2 _7237_/Q _4099_/X VGND VGND VPWR VPWR _4100_/X
+ sky130_fd_sc_hd__a221o_2
XFILLER_96_345 VGND VGND VPWR VPWR sky130_fd_sc_hd__decap_3
XFILLER_96_356 VGND VGND VPWR VPWR sky130_fd_sc_hd__decap_3
XFILLER_2_85 VGND VGND VPWR VPWR sky130_fd_sc_hd__decap_3
XFILLER_77_570 VGND VGND VPWR VPWR sky130_fd_sc_hd__decap_3
XFILLER_64_220 VGND VGND VPWR VPWR sky130_fd_sc_hd__decap_3
XTAP_TAPCELL_ROW_69_1032 VGND VPWR sky130_fd_sc_hd__tapvpwrvgnd_1
XFILLER_25_629 VGND VGND VPWR VPWR sky130_fd_sc_hd__decap_3
XFILLER_52_415 VGND VGND VPWR VPWR sky130_fd_sc_hd__decap_3
XFILLER_92_595 VGND VGND VPWR VPWR sky130_fd_sc_hd__decap_3
XFILLER_17_180 VGND VGND VPWR VPWR sky130_fd_sc_hd__decap_3
XFILLER_64_297 VGND VGND VPWR VPWR sky130_fd_sc_hd__decap_3
X_4933_ _4933_/A0 _4932_/X _4998_/S VGND VGND VPWR VPWR _7266_/D sky130_fd_sc_hd__mux2_2
XTAP_TAPCELL_ROW_63_955 VGND VPWR sky130_fd_sc_hd__tapvpwrvgnd_1
XTAP_TAPCELL_ROW_35_635 VGND VPWR sky130_fd_sc_hd__tapvpwrvgnd_1
XFILLER_20_301 VGND VGND VPWR VPWR sky130_fd_sc_hd__decap_3
XFILLER_20_323 VGND VGND VPWR VPWR sky130_fd_sc_hd__decap_3
XFILLER_32_161 VGND VGND VPWR VPWR sky130_fd_sc_hd__decap_3
X_4864_ _5092_/C _4857_/X _4860_/Y _7000_/D _4878_/A1 VGND VGND VPWR VPWR _4864_/X
+ sky130_fd_sc_hd__a32o_2
X_6603_ _6603_/A VGND VGND VPWR VPWR _6603_/Y sky130_fd_sc_hd__inv_2
X_4795_ _4795_/A _4795_/B VGND VGND VPWR VPWR _4795_/X sky130_fd_sc_hd__xor2_2
X_3815_ _6928_/Q _3926_/A2 _3911_/A2 _6702_/Q VGND VGND VPWR VPWR _3815_/X sky130_fd_sc_hd__a22o_2
X_6534_ _6628_/A VGND VGND VPWR VPWR _6534_/Y sky130_fd_sc_hd__inv_2
X_3746_ _3746_/A _3746_/B _3746_/C VGND VGND VPWR VPWR _3746_/X sky130_fd_sc_hd__and3_2
X_6465_ _6625_/A VGND VGND VPWR VPWR _6465_/Y sky130_fd_sc_hd__inv_2
X_3677_ _6942_/Q VGND VGND VPWR VPWR _3677_/Y sky130_fd_sc_hd__inv_2
X_6396_ _6397_/A VGND VGND VPWR VPWR _6396_/Y sky130_fd_sc_hd__inv_2
XFILLER_102_612 VGND VGND VPWR VPWR sky130_fd_sc_hd__decap_3
XTAP_TAPCELL_ROW_7_316 VGND VPWR sky130_fd_sc_hd__tapvpwrvgnd_1
XFILLER_99_172 VGND VGND VPWR VPWR sky130_fd_sc_hd__decap_3
XFILLER_99_161 VGND VGND VPWR VPWR sky130_fd_sc_hd__decap_3
XFILLER_101_122 VGND VGND VPWR VPWR sky130_fd_sc_hd__decap_3
XFILLER_102_645 VGND VGND VPWR VPWR sky130_fd_sc_hd__decap_3
XFILLER_87_323 VGND VGND VPWR VPWR sky130_fd_sc_hd__decap_3
X_5278_ _5278_/A0 _5107_/X _5292_/S VGND VGND VPWR VPWR _7191_/D sky130_fd_sc_hd__mux2_2
XFILLER_87_356 VGND VGND VPWR VPWR sky130_fd_sc_hd__decap_3
X_7017_ _7357_/CLK _7017_/D _6297_/Y VGND VGND VPWR VPWR _7017_/Q sky130_fd_sc_hd__dfrtp_2
X_4229_ _7099_/Q _4351_/A2 _4351_/B1 _7131_/Q VGND VGND VPWR VPWR _4229_/X sky130_fd_sc_hd__a22o_2
XFILLER_68_592 VGND VGND VPWR VPWR sky130_fd_sc_hd__decap_3
XFILLER_16_607 VGND VGND VPWR VPWR sky130_fd_sc_hd__decap_3
XFILLER_28_467 VGND VGND VPWR VPWR sky130_fd_sc_hd__fill_1
XFILLER_55_220 VGND VGND VPWR VPWR sky130_fd_sc_hd__decap_3
XFILLER_55_231 VGND VGND VPWR VPWR sky130_fd_sc_hd__decap_3
XFILLER_83_540 VGND VGND VPWR VPWR sky130_fd_sc_hd__fill_1
XFILLER_15_106 VGND VGND VPWR VPWR sky130_fd_sc_hd__decap_3
XFILLER_55_297 VGND VGND VPWR VPWR sky130_fd_sc_hd__fill_1
XFILLER_70_223 VGND VGND VPWR VPWR sky130_fd_sc_hd__fill_2
XFILLER_102_97 VGND VGND VPWR VPWR sky130_fd_sc_hd__fill_1
XFILLER_24_640 VGND VGND VPWR VPWR sky130_fd_sc_hd__decap_3
XFILLER_70_256 VGND VGND VPWR VPWR sky130_fd_sc_hd__decap_3
XFILLER_11_323 VGND VGND VPWR VPWR sky130_fd_sc_hd__decap_3
XFILLER_23_150 VGND VGND VPWR VPWR sky130_fd_sc_hd__decap_3
XFILLER_23_172 VGND VGND VPWR VPWR sky130_fd_sc_hd__decap_3
XFILLER_62_79 VGND VGND VPWR VPWR sky130_fd_sc_hd__decap_3
XFILLER_11_378 VGND VGND VPWR VPWR sky130_fd_sc_hd__fill_2
XFILLER_3_500 VGND VGND VPWR VPWR sky130_fd_sc_hd__decap_3
XFILLER_3_544 VGND VGND VPWR VPWR sky130_fd_sc_hd__decap_3
XFILLER_105_461 VGND VGND VPWR VPWR sky130_fd_sc_hd__decap_3
XFILLER_3_588 VGND VGND VPWR VPWR sky130_fd_sc_hd__decap_3
XFILLER_78_301 VGND VGND VPWR VPWR sky130_fd_sc_hd__decap_3
XFILLER_97_109 VGND VGND VPWR VPWR sky130_fd_sc_hd__decap_3
XFILLER_93_337 VGND VGND VPWR VPWR sky130_fd_sc_hd__decap_3
XFILLER_46_253 VGND VGND VPWR VPWR sky130_fd_sc_hd__decap_3
XFILLER_46_286 VGND VGND VPWR VPWR sky130_fd_sc_hd__fill_2
XFILLER_61_223 VGND VGND VPWR VPWR sky130_fd_sc_hd__fill_1
XFILLER_61_234 VGND VGND VPWR VPWR sky130_fd_sc_hd__fill_2
XFILLER_61_256 VGND VGND VPWR VPWR sky130_fd_sc_hd__decap_3
XTAP_TAPCELL_ROW_32_605 VGND VPWR sky130_fd_sc_hd__tapvpwrvgnd_1
XFILLER_14_161 VGND VGND VPWR VPWR sky130_fd_sc_hd__decap_3
XFILLER_30_610 VGND VGND VPWR VPWR sky130_fd_sc_hd__decap_3
XTAP_TAPCELL_ROW_60_925 VGND VPWR sky130_fd_sc_hd__tapvpwrvgnd_1
XFILLER_30_643 VGND VGND VPWR VPWR sky130_fd_sc_hd__fill_1
X_3600_ _3600_/A VGND VGND VPWR VPWR _3600_/Y sky130_fd_sc_hd__inv_2
XTAP_TAPCELL_ROW_40_693 VGND VPWR sky130_fd_sc_hd__tapvpwrvgnd_1
XTAP_TAPCELL_ROW_12_373 VGND VPWR sky130_fd_sc_hd__tapvpwrvgnd_1
XFILLER_6_371 VGND VGND VPWR VPWR sky130_fd_sc_hd__decap_3
Xhold806 _6911_/Q VGND VGND VPWR VPWR _6911_/D sky130_fd_sc_hd__dlygate4sd3_1
Xhold817 _6743_/Q VGND VGND VPWR VPWR _6743_/D sky130_fd_sc_hd__dlygate4sd3_1
Xhold828 _6901_/Q VGND VGND VPWR VPWR _6901_/D sky130_fd_sc_hd__dlygate4sd3_1
Xhold839 _7076_/Q VGND VGND VPWR VPWR _7076_/D sky130_fd_sc_hd__dlygate4sd3_1
Xmax_cap569 _6648_/A VGND VGND VPWR VPWR _6614_/A sky130_fd_sc_hd__buf_2
Xmax_cap558 wire559/X VGND VGND VPWR VPWR _4994_/A2 sky130_fd_sc_hd__clkdlybuf4s25_1
X_3462_ _7249_/Q _4599_/S _3459_/X _3461_/X VGND VGND VPWR VPWR _3462_/X sky130_fd_sc_hd__a211o_2
X_5132_ _5132_/A0 _5131_/X _5132_/S VGND VGND VPWR VPWR _7252_/D sky130_fd_sc_hd__mux2_2
XFILLER_97_643 VGND VGND VPWR VPWR sky130_fd_sc_hd__decap_3
XFILLER_96_120 VGND VGND VPWR VPWR sky130_fd_sc_hd__decap_3
XFILLER_84_304 VGND VGND VPWR VPWR sky130_fd_sc_hd__decap_3
XFILLER_84_315 VGND VGND VPWR VPWR sky130_fd_sc_hd__decap_3
X_5063_ _5063_/A0 _5061_/X _5063_/S VGND VGND VPWR VPWR _7258_/D sky130_fd_sc_hd__mux2_2
XFILLER_96_197 VGND VGND VPWR VPWR sky130_fd_sc_hd__decap_3
XFILLER_96_164 VGND VGND VPWR VPWR sky130_fd_sc_hd__decap_3
XFILLER_37_231 VGND VGND VPWR VPWR sky130_fd_sc_hd__decap_3
XFILLER_84_348 VGND VGND VPWR VPWR sky130_fd_sc_hd__fill_2
XFILLER_37_253 VGND VGND VPWR VPWR sky130_fd_sc_hd__decap_3
XTAP_TAPCELL_ROW_48_782 VGND VPWR sky130_fd_sc_hd__tapvpwrvgnd_1
XFILLER_12_109 VGND VGND VPWR VPWR sky130_fd_sc_hd__decap_3
XFILLER_52_256 VGND VGND VPWR VPWR sky130_fd_sc_hd__fill_2
XFILLER_52_289 VGND VGND VPWR VPWR sky130_fd_sc_hd__decap_3
XFILLER_80_598 VGND VGND VPWR VPWR sky130_fd_sc_hd__decap_3
X_4916_ _4916_/A _4916_/B VGND VGND VPWR VPWR _4967_/A sky130_fd_sc_hd__nand2_2
XFILLER_21_632 VGND VGND VPWR VPWR sky130_fd_sc_hd__decap_3
X_4847_ _4968_/A _4384_/C _4206_/X VGND VGND VPWR VPWR _4904_/B sky130_fd_sc_hd__a21oi_2
XFILLER_20_186 VGND VGND VPWR VPWR sky130_fd_sc_hd__decap_3
XFILLER_20_197 VGND VGND VPWR VPWR sky130_fd_sc_hd__decap_3
X_4778_ _4778_/A _4778_/B VGND VGND VPWR VPWR _4827_/B sky130_fd_sc_hd__and2_2
X_6517_ _6645_/A VGND VGND VPWR VPWR _6517_/Y sky130_fd_sc_hd__inv_2
X_3729_ _6968_/Q _3884_/A2 _3881_/B1 _6962_/Q VGND VGND VPWR VPWR _3729_/X sky130_fd_sc_hd__a22o_2
X_6448_ _6541_/A VGND VGND VPWR VPWR _6448_/Y sky130_fd_sc_hd__inv_2
X_6379_ _6603_/A VGND VGND VPWR VPWR _6379_/Y sky130_fd_sc_hd__inv_2
XFILLER_0_536 VGND VGND VPWR VPWR sky130_fd_sc_hd__decap_3
XFILLER_102_475 VGND VGND VPWR VPWR sky130_fd_sc_hd__fill_1
XFILLER_57_46 VGND VGND VPWR VPWR sky130_fd_sc_hd__fill_1
XFILLER_57_57 VGND VGND VPWR VPWR sky130_fd_sc_hd__decap_3
XFILLER_75_304 VGND VGND VPWR VPWR sky130_fd_sc_hd__decap_3
XFILLER_87_164 VGND VGND VPWR VPWR sky130_fd_sc_hd__decap_3
XFILLER_87_175 VGND VGND VPWR VPWR sky130_fd_sc_hd__decap_3
XFILLER_28_242 VGND VGND VPWR VPWR sky130_fd_sc_hd__decap_3
XFILLER_28_253 VGND VGND VPWR VPWR sky130_fd_sc_hd__decap_3
XFILLER_56_551 VGND VGND VPWR VPWR sky130_fd_sc_hd__decap_3
XFILLER_43_212 VGND VGND VPWR VPWR sky130_fd_sc_hd__decap_3
XFILLER_83_370 VGND VGND VPWR VPWR sky130_fd_sc_hd__decap_3
XFILLER_16_459 VGND VGND VPWR VPWR sky130_fd_sc_hd__decap_3
XFILLER_71_576 VGND VGND VPWR VPWR sky130_fd_sc_hd__decap_3
XFILLER_12_610 VGND VGND VPWR VPWR sky130_fd_sc_hd__decap_3
XFILLER_31_418 VGND VGND VPWR VPWR sky130_fd_sc_hd__decap_3
XFILLER_12_643 VGND VGND VPWR VPWR sky130_fd_sc_hd__fill_1
XFILLER_24_492 VGND VGND VPWR VPWR sky130_fd_sc_hd__decap_3
XFILLER_11_153 VGND VGND VPWR VPWR sky130_fd_sc_hd__decap_3
XFILLER_8_625 VGND VGND VPWR VPWR sky130_fd_sc_hd__decap_3
XFILLER_11_175 VGND VGND VPWR VPWR sky130_fd_sc_hd__decap_3
XFILLER_7_124 VGND VGND VPWR VPWR sky130_fd_sc_hd__fill_1
XFILLER_3_330 VGND VGND VPWR VPWR sky130_fd_sc_hd__decap_3
XFILLER_3_352 VGND VGND VPWR VPWR sky130_fd_sc_hd__decap_3
XFILLER_3_363 VGND VGND VPWR VPWR sky130_fd_sc_hd__decap_3
XFILLER_79_610 VGND VGND VPWR VPWR sky130_fd_sc_hd__decap_3
XFILLER_3_396 VGND VGND VPWR VPWR sky130_fd_sc_hd__fill_1
XFILLER_78_120 VGND VGND VPWR VPWR sky130_fd_sc_hd__decap_3
XFILLER_78_153 VGND VGND VPWR VPWR sky130_fd_sc_hd__fill_2
XFILLER_39_529 VGND VGND VPWR VPWR sky130_fd_sc_hd__fill_1
XFILLER_66_315 VGND VGND VPWR VPWR sky130_fd_sc_hd__decap_3
XFILLER_14_6 VGND VGND VPWR VPWR sky130_fd_sc_hd__fill_1
XFILLER_78_197 VGND VGND VPWR VPWR sky130_fd_sc_hd__decap_3
XFILLER_19_242 VGND VGND VPWR VPWR sky130_fd_sc_hd__decap_3
XFILLER_47_573 VGND VGND VPWR VPWR sky130_fd_sc_hd__decap_3
XFILLER_81_318 VGND VGND VPWR VPWR sky130_fd_sc_hd__fill_2
XFILLER_93_178 VGND VGND VPWR VPWR sky130_fd_sc_hd__decap_3
XFILLER_19_286 VGND VGND VPWR VPWR sky130_fd_sc_hd__decap_3
XFILLER_19_297 VGND VGND VPWR VPWR sky130_fd_sc_hd__decap_3
XFILLER_62_554 VGND VGND VPWR VPWR sky130_fd_sc_hd__decap_3
XTAP_TAPCELL_ROW_45_752 VGND VPWR sky130_fd_sc_hd__tapvpwrvgnd_1
XTAP_TAPCELL_ROW_17_432 VGND VPWR sky130_fd_sc_hd__tapvpwrvgnd_1
XFILLER_34_278 VGND VGND VPWR VPWR sky130_fd_sc_hd__decap_3
XFILLER_34_289 VGND VGND VPWR VPWR sky130_fd_sc_hd__decap_3
XFILLER_62_587 VGND VGND VPWR VPWR sky130_fd_sc_hd__fill_1
XFILLER_97_3 VGND VGND VPWR VPWR sky130_fd_sc_hd__decap_3
XFILLER_15_492 VGND VGND VPWR VPWR sky130_fd_sc_hd__decap_3
XFILLER_30_440 VGND VGND VPWR VPWR sky130_fd_sc_hd__decap_3
X_4701_ _6989_/Q _6990_/Q _5044_/A VGND VGND VPWR VPWR _5026_/A sky130_fd_sc_hd__and3_2
XFILLER_30_462 VGND VGND VPWR VPWR sky130_fd_sc_hd__decap_3
X_4632_ _4626_/X _4274_/Y _4631_/X VGND VGND VPWR VPWR _4916_/B sky130_fd_sc_hd__a21oi_2
XFILLER_8_73 VGND VGND VPWR VPWR sky130_fd_sc_hd__decap_3
X_7351_ _7355_/CLK _7351_/D _6631_/Y VGND VGND VPWR VPWR _7351_/Q sky130_fd_sc_hd__dfrtp_2
Xhold603 _6751_/Q VGND VGND VPWR VPWR _6751_/D sky130_fd_sc_hd__dlygate4sd3_1
X_4563_ _4563_/A _4563_/B VGND VGND VPWR VPWR _7299_/D sky130_fd_sc_hd__and2_2
XTAP_TAPCELL_ROW_77_1120 VGND VPWR sky130_fd_sc_hd__tapvpwrvgnd_1
X_7282_ _7355_/CLK _7282_/D _6562_/Y VGND VGND VPWR VPWR _7282_/Q sky130_fd_sc_hd__dfrtp_2
Xhold614 _6785_/Q VGND VGND VPWR VPWR _6785_/D sky130_fd_sc_hd__dlygate4sd3_1
Xhold625 _6729_/Q VGND VGND VPWR VPWR _6729_/D sky130_fd_sc_hd__dlygate4sd3_1
Xhold636 _6851_/Q VGND VGND VPWR VPWR _6851_/D sky130_fd_sc_hd__dlygate4sd3_1
X_6302_ _6556_/A VGND VGND VPWR VPWR _6302_/Y sky130_fd_sc_hd__inv_2
XFILLER_6_190 VGND VGND VPWR VPWR sky130_fd_sc_hd__decap_3
XFILLER_89_407 VGND VGND VPWR VPWR sky130_fd_sc_hd__fill_1
XFILLER_89_429 VGND VGND VPWR VPWR sky130_fd_sc_hd__decap_3
Xhold647 _6794_/Q VGND VGND VPWR VPWR _6794_/D sky130_fd_sc_hd__dlygate4sd3_1
Xhold658 _6730_/Q VGND VGND VPWR VPWR _6730_/D sky130_fd_sc_hd__dlygate4sd3_1
Xhold669 _6844_/Q VGND VGND VPWR VPWR _6844_/D sky130_fd_sc_hd__dlygate4sd3_1
X_3376_ _3376_/A _3376_/B VGND VGND VPWR VPWR _3376_/Y sky130_fd_sc_hd__nor2_2
X_5115_ _5101_/A _4292_/C _5113_/Y _5020_/A _5114_/Y VGND VGND VPWR VPWR _5115_/X
+ sky130_fd_sc_hd__o221a_2
XFILLER_97_473 VGND VGND VPWR VPWR sky130_fd_sc_hd__decap_3
XFILLER_57_337 VGND VGND VPWR VPWR sky130_fd_sc_hd__fill_2
X_5046_ _5101_/B VGND VGND VPWR VPWR _5100_/A sky130_fd_sc_hd__inv_2
XFILLER_72_318 VGND VGND VPWR VPWR sky130_fd_sc_hd__decap_3
XFILLER_84_178 VGND VGND VPWR VPWR sky130_fd_sc_hd__decap_3
XFILLER_53_521 VGND VGND VPWR VPWR sky130_fd_sc_hd__fill_2
XFILLER_13_407 VGND VGND VPWR VPWR sky130_fd_sc_hd__decap_3
XFILLER_25_234 VGND VGND VPWR VPWR sky130_fd_sc_hd__decap_3
XFILLER_53_576 VGND VGND VPWR VPWR sky130_fd_sc_hd__fill_1
X_6997_ _7406_/CLK _6997_/D _6277_/Y VGND VGND VPWR VPWR _6997_/Q sky130_fd_sc_hd__dfrtp_2
XFILLER_40_215 VGND VGND VPWR VPWR sky130_fd_sc_hd__decap_3
XFILLER_80_395 VGND VGND VPWR VPWR sky130_fd_sc_hd__decap_3
XFILLER_21_440 VGND VGND VPWR VPWR sky130_fd_sc_hd__decap_3
XFILLER_40_259 VGND VGND VPWR VPWR sky130_fd_sc_hd__decap_3
XFILLER_21_495 VGND VGND VPWR VPWR sky130_fd_sc_hd__decap_3
XFILLER_5_606 VGND VGND VPWR VPWR sky130_fd_sc_hd__decap_3
XFILLER_5_617 VGND VGND VPWR VPWR sky130_fd_sc_hd__decap_3
XFILLER_4_127 VGND VGND VPWR VPWR sky130_fd_sc_hd__fill_1
XFILLER_4_149 VGND VGND VPWR VPWR sky130_fd_sc_hd__fill_1
XFILLER_108_41 VGND VGND VPWR VPWR sky130_fd_sc_hd__decap_3
XFILLER_108_63 VGND VGND VPWR VPWR sky130_fd_sc_hd__decap_3
XFILLER_108_85 VGND VGND VPWR VPWR sky130_fd_sc_hd__decap_3
XFILLER_0_333 VGND VGND VPWR VPWR sky130_fd_sc_hd__decap_3
XFILLER_88_451 VGND VGND VPWR VPWR sky130_fd_sc_hd__decap_3
XFILLER_48_315 VGND VGND VPWR VPWR sky130_fd_sc_hd__decap_3
XFILLER_76_635 VGND VGND VPWR VPWR sky130_fd_sc_hd__decap_3
XFILLER_0_399 VGND VGND VPWR VPWR sky130_fd_sc_hd__decap_3
XFILLER_75_123 VGND VGND VPWR VPWR sky130_fd_sc_hd__decap_3
XFILLER_75_145 VGND VGND VPWR VPWR sky130_fd_sc_hd__decap_3
XFILLER_75_167 VGND VGND VPWR VPWR sky130_fd_sc_hd__fill_1
XFILLER_44_510 VGND VGND VPWR VPWR sky130_fd_sc_hd__fill_1
XFILLER_63_329 VGND VGND VPWR VPWR sky130_fd_sc_hd__decap_3
Xplace318 _4260_/A2 VGND VGND VPWR VPWR _4601_/S sky130_fd_sc_hd__buf_2
Xplace307 _3586_/Y VGND VGND VPWR VPWR _3600_/A sky130_fd_sc_hd__buf_2
XFILLER_17_60 VGND VGND VPWR VPWR sky130_fd_sc_hd__decap_3
XFILLER_17_82 VGND VGND VPWR VPWR sky130_fd_sc_hd__decap_3
XFILLER_71_340 VGND VGND VPWR VPWR sky130_fd_sc_hd__decap_3
Xplace329 _3423_/C VGND VGND VPWR VPWR _5708_/S sky130_fd_sc_hd__buf_2
XTAP_TAPCELL_ROW_42_722 VGND VPWR sky130_fd_sc_hd__tapvpwrvgnd_1
XFILLER_31_259 VGND VGND VPWR VPWR sky130_fd_sc_hd__decap_3
XFILLER_12_484 VGND VGND VPWR VPWR sky130_fd_sc_hd__fill_1
XFILLER_33_81 VGND VGND VPWR VPWR sky130_fd_sc_hd__decap_3
XFILLER_8_477 VGND VGND VPWR VPWR sky130_fd_sc_hd__decap_3
XTAP_TAPCELL_ROW_22_490 VGND VPWR sky130_fd_sc_hd__tapvpwrvgnd_1
XTAP_TAPCELL_ROW_72_1061 VGND VPWR sky130_fd_sc_hd__tapvpwrvgnd_1
XFILLER_98_259 VGND VGND VPWR VPWR sky130_fd_sc_hd__decap_3
XFILLER_100_209 VGND VGND VPWR VPWR sky130_fd_sc_hd__fill_1
XFILLER_39_315 VGND VGND VPWR VPWR sky130_fd_sc_hd__decap_3
XFILLER_39_326 VGND VGND VPWR VPWR sky130_fd_sc_hd__fill_2
XFILLER_79_473 VGND VGND VPWR VPWR sky130_fd_sc_hd__decap_3
XFILLER_12_3 VGND VGND VPWR VPWR sky130_fd_sc_hd__fill_2
XFILLER_39_337 VGND VGND VPWR VPWR sky130_fd_sc_hd__decap_3
XFILLER_39_348 VGND VGND VPWR VPWR sky130_fd_sc_hd__decap_3
XFILLER_39_359 VGND VGND VPWR VPWR sky130_fd_sc_hd__decap_3
XFILLER_67_646 VGND VGND VPWR VPWR sky130_fd_sc_hd__fill_2
XFILLER_94_421 VGND VGND VPWR VPWR sky130_fd_sc_hd__decap_3
XFILLER_94_454 VGND VGND VPWR VPWR sky130_fd_sc_hd__fill_2
XFILLER_66_189 VGND VGND VPWR VPWR sky130_fd_sc_hd__decap_3
XFILLER_82_638 VGND VGND VPWR VPWR sky130_fd_sc_hd__decap_3
X_6920_ clkload6/A _6920_/D VGND VGND VPWR VPWR _6920_/Q sky130_fd_sc_hd__dfxtp_2
XFILLER_81_159 VGND VGND VPWR VPWR sky130_fd_sc_hd__decap_3
X_6851_ clkload3/A _6851_/D VGND VGND VPWR VPWR _6851_/Q sky130_fd_sc_hd__dfxtp_2
Xfanout19 _6260_/A VGND VGND VPWR VPWR _6662_/A sky130_fd_sc_hd__clkdlybuf4s25_1
XFILLER_22_226 VGND VGND VPWR VPWR sky130_fd_sc_hd__decap_3
XFILLER_50_568 VGND VGND VPWR VPWR sky130_fd_sc_hd__decap_3
X_6782_ clkload4/A _6782_/D VGND VGND VPWR VPWR _6782_/Q sky130_fd_sc_hd__dfxtp_2
X_3994_ _7345_/Q _3993_/X _3994_/S VGND VGND VPWR VPWR _7345_/D sky130_fd_sc_hd__mux2_2
XTAP_TAPCELL_ROW_83_1190 VGND VPWR sky130_fd_sc_hd__tapvpwrvgnd_1
X_5733_ _7372_/Q hold941/X _5737_/S VGND VGND VPWR VPWR _6716_/D sky130_fd_sc_hd__mux2_2
X_5664_ _5664_/A _5664_/B _5664_/C _5664_/D VGND VGND VPWR VPWR _5665_/D sky130_fd_sc_hd__and4_2
X_7403_ _7405_/CLK _7403_/D _6683_/Y VGND VGND VPWR VPWR _7403_/Q sky130_fd_sc_hd__dfrtp_2
X_5595_ _5595_/A _5595_/B VGND VGND VPWR VPWR _7030_/D sky130_fd_sc_hd__or2_2
X_4615_ _4294_/A _4612_/B _3610_/A VGND VGND VPWR VPWR _4615_/Y sky130_fd_sc_hd__a21oi_2
X_7334_ _7366_/CLK _7334_/D _6614_/Y VGND VGND VPWR VPWR _7334_/Q sky130_fd_sc_hd__dfrtp_2
X_4546_ _7307_/Q _4563_/B VGND VGND VPWR VPWR _7307_/D sky130_fd_sc_hd__and2_2
XFILLER_89_204 VGND VGND VPWR VPWR sky130_fd_sc_hd__decap_3
XFILLER_104_548 VGND VGND VPWR VPWR sky130_fd_sc_hd__fill_2
X_7265_ _7269_/CLK _7265_/D _6545_/Y VGND VGND VPWR VPWR _7265_/Q sky130_fd_sc_hd__dfrtp_2
X_7196_ _7387_/CLK _7196_/D _6476_/Y VGND VGND VPWR VPWR _7196_/Q sky130_fd_sc_hd__dfrtp_2
Xhold1100 _7300_/Q VGND VGND VPWR VPWR _4561_/A sky130_fd_sc_hd__dlygate4sd3_1
X_3359_ _6983_/Q _5130_/A VGND VGND VPWR VPWR _3376_/A sky130_fd_sc_hd__or2_2
XFILLER_85_421 VGND VGND VPWR VPWR sky130_fd_sc_hd__decap_3
Xhold1111 _7170_/Q VGND VGND VPWR VPWR _5321_/A0 sky130_fd_sc_hd__dlygate4sd3_1
Xhold1122 _7136_/Q VGND VGND VPWR VPWR _5394_/A0 sky130_fd_sc_hd__dlygate4sd3_1
Xhold1133 _7144_/Q VGND VGND VPWR VPWR _5377_/A0 sky130_fd_sc_hd__dlygate4sd3_1
XFILLER_45_318 VGND VGND VPWR VPWR sky130_fd_sc_hd__decap_3
Xhold1144 _7166_/Q VGND VGND VPWR VPWR _5329_/A0 sky130_fd_sc_hd__dlygate4sd3_1
Xhold1155 _7228_/Q VGND VGND VPWR VPWR _5200_/A sky130_fd_sc_hd__dlygate4sd3_1
Xhold1166 _7164_/Q VGND VGND VPWR VPWR _5333_/A0 sky130_fd_sc_hd__dlygate4sd3_1
XTAP_TAPCELL_ROW_86_1219 VGND VPWR sky130_fd_sc_hd__tapvpwrvgnd_1
XFILLER_85_498 VGND VGND VPWR VPWR sky130_fd_sc_hd__decap_3
Xhold1177 _7304_/Q VGND VGND VPWR VPWR _4552_/A sky130_fd_sc_hd__dlygate4sd3_1
Xhold1188 _7122_/Q VGND VGND VPWR VPWR _5423_/A0 sky130_fd_sc_hd__dlygate4sd3_1
Xhold1199 _7284_/Q VGND VGND VPWR VPWR _4593_/A sky130_fd_sc_hd__dlygate4sd3_1
XFILLER_53_340 VGND VGND VPWR VPWR sky130_fd_sc_hd__decap_3
XFILLER_13_204 VGND VGND VPWR VPWR sky130_fd_sc_hd__decap_3
XFILLER_26_587 VGND VGND VPWR VPWR sky130_fd_sc_hd__fill_1
XFILLER_13_237 VGND VGND VPWR VPWR sky130_fd_sc_hd__decap_3
XFILLER_80_181 VGND VGND VPWR VPWR sky130_fd_sc_hd__decap_3
XFILLER_9_208 VGND VGND VPWR VPWR sky130_fd_sc_hd__decap_3
XFILLER_21_281 VGND VGND VPWR VPWR sky130_fd_sc_hd__decap_3
XTAP_TAPCELL_ROW_97_1348 VGND VPWR sky130_fd_sc_hd__tapvpwrvgnd_1
XFILLER_5_425 VGND VGND VPWR VPWR sky130_fd_sc_hd__decap_3
XFILLER_79_11 VGND VGND VPWR VPWR sky130_fd_sc_hd__fill_1
XFILLER_1_620 VGND VGND VPWR VPWR sky130_fd_sc_hd__decap_3
XFILLER_0_152 VGND VGND VPWR VPWR sky130_fd_sc_hd__decap_3
XFILLER_103_570 VGND VGND VPWR VPWR sky130_fd_sc_hd__decap_3
XFILLER_76_410 VGND VGND VPWR VPWR sky130_fd_sc_hd__fill_1
XFILLER_95_207 VGND VGND VPWR VPWR sky130_fd_sc_hd__decap_3
XFILLER_49_635 VGND VGND VPWR VPWR sky130_fd_sc_hd__decap_3
XFILLER_76_421 VGND VGND VPWR VPWR sky130_fd_sc_hd__fill_1
XFILLER_95_54 VGND VGND VPWR VPWR sky130_fd_sc_hd__fill_2
XFILLER_36_307 VGND VGND VPWR VPWR sky130_fd_sc_hd__fill_1
XFILLER_48_167 VGND VGND VPWR VPWR sky130_fd_sc_hd__decap_3
XFILLER_91_402 VGND VGND VPWR VPWR sky130_fd_sc_hd__decap_3
XFILLER_28_70 VGND VGND VPWR VPWR sky130_fd_sc_hd__decap_3
XFILLER_64_638 VGND VGND VPWR VPWR sky130_fd_sc_hd__decap_3
XFILLER_76_498 VGND VGND VPWR VPWR sky130_fd_sc_hd__decap_3
XFILLER_91_413 VGND VGND VPWR VPWR sky130_fd_sc_hd__decap_3
XFILLER_17_532 VGND VGND VPWR VPWR sky130_fd_sc_hd__decap_3
XFILLER_63_148 VGND VGND VPWR VPWR sky130_fd_sc_hd__decap_3
XFILLER_32_502 VGND VGND VPWR VPWR sky130_fd_sc_hd__decap_3
XFILLER_44_384 VGND VGND VPWR VPWR sky130_fd_sc_hd__decap_3
XTAP_TAPCELL_ROW_106_1455 VGND VPWR sky130_fd_sc_hd__tapvpwrvgnd_1
XFILLER_32_568 VGND VGND VPWR VPWR sky130_fd_sc_hd__decap_3
XFILLER_44_91 VGND VGND VPWR VPWR sky130_fd_sc_hd__decap_3
XFILLER_12_281 VGND VGND VPWR VPWR sky130_fd_sc_hd__decap_3
XFILLER_81_6 VGND VGND VPWR VPWR sky130_fd_sc_hd__decap_3
XFILLER_8_230 VGND VGND VPWR VPWR sky130_fd_sc_hd__decap_3
XFILLER_8_296 VGND VGND VPWR VPWR sky130_fd_sc_hd__decap_3
X_4400_ _7178_/Q _4459_/C1 _4428_/B1 _7146_/Q _4399_/X VGND VGND VPWR VPWR _4400_/X
+ sky130_fd_sc_hd__a221o_2
Xoutput527 _6996_/Q VGND VGND VPWR VPWR pc_out[19] sky130_fd_sc_hd__clkdlybuf4s25_1
Xoutput516 _5646_/Y VGND VGND VPWR VPWR instruction_out[9] sky130_fd_sc_hd__clkdlybuf4s25_1
Xoutput505 _5649_/X VGND VGND VPWR VPWR instruction_out[26] sky130_fd_sc_hd__clkdlybuf4s25_1
Xoutput538 _7006_/Q VGND VGND VPWR VPWR pc_out[29] sky130_fd_sc_hd__clkdlybuf4s25_1
X_4331_ _7223_/Q _4353_/A2 _3488_/B _7036_/Q VGND VGND VPWR VPWR _4331_/X sky130_fd_sc_hd__a22o_2
XFILLER_4_480 VGND VGND VPWR VPWR sky130_fd_sc_hd__fill_2
XFILLER_4_491 VGND VGND VPWR VPWR sky130_fd_sc_hd__decap_3
X_7050_ _7269_/CLK _7050_/D _6330_/Y VGND VGND VPWR VPWR _7050_/Q sky130_fd_sc_hd__dfrtp_2
X_4262_ _7230_/Q _4349_/B1 _4244_/B _7294_/Q VGND VGND VPWR VPWR _4262_/X sky130_fd_sc_hd__a22o_2
XFILLER_99_557 VGND VGND VPWR VPWR sky130_fd_sc_hd__decap_3
XFILLER_101_529 VGND VGND VPWR VPWR sky130_fd_sc_hd__decap_3
XFILLER_67_443 VGND VGND VPWR VPWR sky130_fd_sc_hd__decap_3
XFILLER_79_281 VGND VGND VPWR VPWR sky130_fd_sc_hd__decap_3
X_4193_ _7359_/Q _4270_/B _4351_/A2 _7103_/Q VGND VGND VPWR VPWR _4193_/X sky130_fd_sc_hd__a22o_2
XFILLER_27_307 VGND VGND VPWR VPWR sky130_fd_sc_hd__decap_3
XFILLER_39_167 VGND VGND VPWR VPWR sky130_fd_sc_hd__fill_1
XFILLER_54_126 VGND VGND VPWR VPWR sky130_fd_sc_hd__decap_3
XFILLER_55_638 VGND VGND VPWR VPWR sky130_fd_sc_hd__decap_3
XFILLER_67_498 VGND VGND VPWR VPWR sky130_fd_sc_hd__decap_3
XFILLER_82_424 VGND VGND VPWR VPWR sky130_fd_sc_hd__decap_3
XFILLER_94_284 VGND VGND VPWR VPWR sky130_fd_sc_hd__decap_3
XFILLER_54_159 VGND VGND VPWR VPWR sky130_fd_sc_hd__fill_2
XFILLER_70_619 VGND VGND VPWR VPWR sky130_fd_sc_hd__decap_3
XFILLER_82_457 VGND VGND VPWR VPWR sky130_fd_sc_hd__decap_3
X_6903_ _6976_/CLK _6903_/D VGND VGND VPWR VPWR _6903_/Q sky130_fd_sc_hd__dfxtp_2
XFILLER_23_502 VGND VGND VPWR VPWR sky130_fd_sc_hd__fill_2
XFILLER_35_373 VGND VGND VPWR VPWR sky130_fd_sc_hd__decap_3
XTAP_TAPCELL_ROW_53_839 VGND VPWR sky130_fd_sc_hd__tapvpwrvgnd_1
XTAP_TAPCELL_ROW_25_519 VGND VPWR sky130_fd_sc_hd__tapvpwrvgnd_1
XFILLER_50_332 VGND VGND VPWR VPWR sky130_fd_sc_hd__fill_1
XFILLER_62_170 VGND VGND VPWR VPWR sky130_fd_sc_hd__decap_3
XFILLER_62_181 VGND VGND VPWR VPWR sky130_fd_sc_hd__fill_1
X_6834_ clkload8/A _6834_/D VGND VGND VPWR VPWR _6834_/Q sky130_fd_sc_hd__dfxtp_2
XFILLER_50_365 VGND VGND VPWR VPWR sky130_fd_sc_hd__decap_3
X_6765_ _6963_/CLK _6765_/D VGND VGND VPWR VPWR _6765_/Q sky130_fd_sc_hd__dfxtp_2
X_3977_ _7352_/Q hold965/X _3989_/S VGND VGND VPWR VPWR _7352_/D sky130_fd_sc_hd__mux2_2
XFILLER_10_218 VGND VGND VPWR VPWR sky130_fd_sc_hd__decap_3
XFILLER_40_27 VGND VGND VPWR VPWR sky130_fd_sc_hd__fill_1
X_6696_ clkload9/A _6696_/D VGND VGND VPWR VPWR _6696_/Q sky130_fd_sc_hd__dfxtp_2
XFILLER_108_128 VGND VGND VPWR VPWR sky130_fd_sc_hd__decap_3
XFILLER_40_49 VGND VGND VPWR VPWR sky130_fd_sc_hd__fill_1
X_5647_ _5647_/A _5647_/B VGND VGND VPWR VPWR _5647_/Y sky130_fd_sc_hd__nand2_2
X_7317_ _7350_/CLK _7317_/D _6597_/Y VGND VGND VPWR VPWR _7317_/Q sky130_fd_sc_hd__dfrtp_2
XFILLER_104_356 VGND VGND VPWR VPWR sky130_fd_sc_hd__decap_3
X_7248_ _7376_/CLK _7248_/D _6528_/Y VGND VGND VPWR VPWR _7248_/Q sky130_fd_sc_hd__dfrtp_2
XFILLER_104_389 VGND VGND VPWR VPWR sky130_fd_sc_hd__decap_3
XTAP_TAPCELL_ROW_92_1289 VGND VPWR sky130_fd_sc_hd__tapvpwrvgnd_1
XFILLER_105_20 VGND VGND VPWR VPWR sky130_fd_sc_hd__decap_3
X_7179_ _7363_/CLK _7179_/D _6459_/Y VGND VGND VPWR VPWR _7179_/Q sky130_fd_sc_hd__dfrtp_2
XFILLER_105_53 VGND VGND VPWR VPWR sky130_fd_sc_hd__decap_3
XFILLER_105_75 VGND VGND VPWR VPWR sky130_fd_sc_hd__fill_1
XFILLER_58_465 VGND VGND VPWR VPWR sky130_fd_sc_hd__decap_3
XFILLER_73_402 VGND VGND VPWR VPWR sky130_fd_sc_hd__decap_3
XFILLER_85_240 VGND VGND VPWR VPWR sky130_fd_sc_hd__fill_2
XFILLER_85_262 VGND VGND VPWR VPWR sky130_fd_sc_hd__decap_3
XTAP_TAPCELL_ROW_5_288 VGND VPWR sky130_fd_sc_hd__tapvpwrvgnd_1
XFILLER_46_638 VGND VGND VPWR VPWR sky130_fd_sc_hd__decap_3
XFILLER_65_57 VGND VGND VPWR VPWR sky130_fd_sc_hd__fill_1
XFILLER_73_435 VGND VGND VPWR VPWR sky130_fd_sc_hd__fill_1
XFILLER_45_148 VGND VGND VPWR VPWR sky130_fd_sc_hd__decap_3
XFILLER_60_107 VGND VGND VPWR VPWR sky130_fd_sc_hd__decap_3
XFILLER_26_395 VGND VGND VPWR VPWR sky130_fd_sc_hd__decap_3
XFILLER_41_332 VGND VGND VPWR VPWR sky130_fd_sc_hd__decap_3
XFILLER_53_181 VGND VGND VPWR VPWR sky130_fd_sc_hd__decap_3
XFILLER_60_129 VGND VGND VPWR VPWR sky130_fd_sc_hd__fill_1
XFILLER_14_568 VGND VGND VPWR VPWR sky130_fd_sc_hd__decap_3
XFILLER_14_83 VGND VGND VPWR VPWR sky130_fd_sc_hd__fill_1
XTAP_TAPCELL_ROW_101_1396 VGND VPWR sky130_fd_sc_hd__tapvpwrvgnd_1
XFILLER_5_200 VGND VGND VPWR VPWR sky130_fd_sc_hd__fill_1
XFILLER_107_150 VGND VGND VPWR VPWR sky130_fd_sc_hd__decap_3
XFILLER_107_172 VGND VGND VPWR VPWR sky130_fd_sc_hd__decap_3
XFILLER_30_82 VGND VGND VPWR VPWR sky130_fd_sc_hd__fill_2
XFILLER_5_266 VGND VGND VPWR VPWR sky130_fd_sc_hd__decap_3
XFILLER_68_218 VGND VGND VPWR VPWR sky130_fd_sc_hd__decap_3
XFILLER_37_638 VGND VGND VPWR VPWR sky130_fd_sc_hd__decap_3
XFILLER_49_498 VGND VGND VPWR VPWR sky130_fd_sc_hd__decap_3
XFILLER_64_413 VGND VGND VPWR VPWR sky130_fd_sc_hd__decap_3
XFILLER_64_435 VGND VGND VPWR VPWR sky130_fd_sc_hd__decap_3
XFILLER_76_262 VGND VGND VPWR VPWR sky130_fd_sc_hd__decap_3
XFILLER_36_159 VGND VGND VPWR VPWR sky130_fd_sc_hd__decap_3
XFILLER_91_243 VGND VGND VPWR VPWR sky130_fd_sc_hd__decap_3
XFILLER_91_276 VGND VGND VPWR VPWR sky130_fd_sc_hd__decap_3
XFILLER_32_332 VGND VGND VPWR VPWR sky130_fd_sc_hd__decap_3
XFILLER_60_630 VGND VGND VPWR VPWR sky130_fd_sc_hd__decap_3
X_3900_ _3898_/X _3899_/X _5151_/A VGND VGND VPWR VPWR _3900_/Y sky130_fd_sc_hd__o21ai_2
XFILLER_32_365 VGND VGND VPWR VPWR sky130_fd_sc_hd__decap_3
X_3831_ _3682_/A _3828_/X _3830_/X _3714_/X VGND VGND VPWR VPWR _3831_/X sky130_fd_sc_hd__a22o_2
XTAP_TAPCELL_ROW_50_809 VGND VPWR sky130_fd_sc_hd__tapvpwrvgnd_1
XFILLER_20_527 VGND VGND VPWR VPWR sky130_fd_sc_hd__decap_3
X_6550_ _6552_/A VGND VGND VPWR VPWR _6550_/Y sky130_fd_sc_hd__inv_2
X_3762_ _3746_/C _3759_/X _3760_/X _3867_/B1 VGND VGND VPWR VPWR _3762_/X sky130_fd_sc_hd__o31a_2
XTAP_TAPCELL_ROW_80_1160 VGND VPWR sky130_fd_sc_hd__tapvpwrvgnd_1
XFILLER_9_561 VGND VGND VPWR VPWR sky130_fd_sc_hd__decap_3
X_6481_ _6485_/A VGND VGND VPWR VPWR _6481_/Y sky130_fd_sc_hd__inv_2
X_3693_ _3693_/A0 _3692_/X _4832_/A VGND VGND VPWR VPWR _7403_/D sky130_fd_sc_hd__mux2_2
XTAP_TAPCELL_ROW_30_577 VGND VPWR sky130_fd_sc_hd__tapvpwrvgnd_1
XFILLER_9_594 VGND VGND VPWR VPWR sky130_fd_sc_hd__decap_3
X_7102_ _7280_/CLK _7102_/D _6382_/Y VGND VGND VPWR VPWR _7102_/Q sky130_fd_sc_hd__dfrtp_2
X_4314_ _4376_/A _4364_/A _4364_/B _4313_/D VGND VGND VPWR VPWR _4315_/B sky130_fd_sc_hd__o31ai_2
XFILLER_99_343 VGND VGND VPWR VPWR sky130_fd_sc_hd__fill_1
XFILLER_59_207 VGND VGND VPWR VPWR sky130_fd_sc_hd__decap_3
XFILLER_59_218 VGND VGND VPWR VPWR sky130_fd_sc_hd__decap_3
XFILLER_87_505 VGND VGND VPWR VPWR sky130_fd_sc_hd__decap_3
X_5294_ _5294_/A _5294_/B VGND VGND VPWR VPWR _5294_/Y sky130_fd_sc_hd__nor2_2
XFILLER_101_315 VGND VGND VPWR VPWR sky130_fd_sc_hd__decap_3
XFILLER_101_337 VGND VGND VPWR VPWR sky130_fd_sc_hd__decap_3
XFILLER_101_348 VGND VGND VPWR VPWR sky130_fd_sc_hd__decap_3
XFILLER_19_28 VGND VGND VPWR VPWR sky130_fd_sc_hd__decap_3
XFILLER_87_549 VGND VGND VPWR VPWR sky130_fd_sc_hd__decap_3
X_7033_ _7380_/CLK _7033_/D _6313_/Y VGND VGND VPWR VPWR _7033_/Q sky130_fd_sc_hd__dfrtp_2
X_4245_ _7357_/Q _4261_/A2 _4348_/A2 _7165_/Q _4244_/X VGND VGND VPWR VPWR _4248_/B
+ sky130_fd_sc_hd__a221o_2
XFILLER_28_616 VGND VGND VPWR VPWR sky130_fd_sc_hd__decap_3
X_4176_ _7168_/Q _4261_/B1 _4420_/B1 _7136_/Q VGND VGND VPWR VPWR _4176_/X sky130_fd_sc_hd__a22o_2
XFILLER_55_424 VGND VGND VPWR VPWR sky130_fd_sc_hd__decap_3
XFILLER_67_284 VGND VGND VPWR VPWR sky130_fd_sc_hd__decap_3
XFILLER_27_159 VGND VGND VPWR VPWR sky130_fd_sc_hd__decap_3
XTAP_TAPCELL_ROW_2_258 VGND VPWR sky130_fd_sc_hd__tapvpwrvgnd_1
XFILLER_70_416 VGND VGND VPWR VPWR sky130_fd_sc_hd__decap_3
XFILLER_70_427 VGND VGND VPWR VPWR sky130_fd_sc_hd__decap_3
XTAP_TAPCELL_ROW_66_997 VGND VPWR sky130_fd_sc_hd__tapvpwrvgnd_1
XTAP_TAPCELL_ROW_38_677 VGND VPWR sky130_fd_sc_hd__tapvpwrvgnd_1
XTAP_TAPCELL_ROW_38_666 VGND VPWR sky130_fd_sc_hd__tapvpwrvgnd_1
XFILLER_42_129 VGND VGND VPWR VPWR sky130_fd_sc_hd__decap_3
XFILLER_51_641 VGND VGND VPWR VPWR sky130_fd_sc_hd__decap_3
XFILLER_70_449 VGND VGND VPWR VPWR sky130_fd_sc_hd__fill_2
XFILLER_82_298 VGND VGND VPWR VPWR sky130_fd_sc_hd__decap_3
XFILLER_11_505 VGND VGND VPWR VPWR sky130_fd_sc_hd__decap_3
XFILLER_23_354 VGND VGND VPWR VPWR sky130_fd_sc_hd__fill_1
X_6817_ clkload6/A _6817_/D VGND VGND VPWR VPWR _6817_/Q sky130_fd_sc_hd__dfxtp_2
XFILLER_50_162 VGND VGND VPWR VPWR sky130_fd_sc_hd__decap_3
X_6748_ clkload3/A _6748_/D VGND VGND VPWR VPWR _6748_/Q sky130_fd_sc_hd__dfxtp_2
X_6679_ _6684_/A VGND VGND VPWR VPWR _6679_/Y sky130_fd_sc_hd__inv_2
XTAP_TAPCELL_ROW_94_1318 VGND VPWR sky130_fd_sc_hd__tapvpwrvgnd_1
XFILLER_105_632 VGND VGND VPWR VPWR sky130_fd_sc_hd__decap_3
XFILLER_2_236 VGND VGND VPWR VPWR sky130_fd_sc_hd__decap_3
XFILLER_104_153 VGND VGND VPWR VPWR sky130_fd_sc_hd__decap_3
XFILLER_104_197 VGND VGND VPWR VPWR sky130_fd_sc_hd__decap_3
XFILLER_76_56 VGND VGND VPWR VPWR sky130_fd_sc_hd__decap_3
XFILLER_19_638 VGND VGND VPWR VPWR sky130_fd_sc_hd__decap_3
XFILLER_46_424 VGND VGND VPWR VPWR sky130_fd_sc_hd__fill_2
XFILLER_58_262 VGND VGND VPWR VPWR sky130_fd_sc_hd__decap_3
XFILLER_73_210 VGND VGND VPWR VPWR sky130_fd_sc_hd__decap_3
XFILLER_86_582 VGND VGND VPWR VPWR sky130_fd_sc_hd__decap_3
XFILLER_86_593 VGND VGND VPWR VPWR sky130_fd_sc_hd__decap_3
XFILLER_18_126 VGND VGND VPWR VPWR sky130_fd_sc_hd__decap_3
XFILLER_18_159 VGND VGND VPWR VPWR sky130_fd_sc_hd__decap_3
XFILLER_46_435 VGND VGND VPWR VPWR sky130_fd_sc_hd__fill_2
XFILLER_46_468 VGND VGND VPWR VPWR sky130_fd_sc_hd__decap_3
XFILLER_73_243 VGND VGND VPWR VPWR sky130_fd_sc_hd__fill_1
XFILLER_61_405 VGND VGND VPWR VPWR sky130_fd_sc_hd__decap_3
XFILLER_61_427 VGND VGND VPWR VPWR sky130_fd_sc_hd__decap_3
XFILLER_73_265 VGND VGND VPWR VPWR sky130_fd_sc_hd__decap_3
XFILLER_33_129 VGND VGND VPWR VPWR sky130_fd_sc_hd__fill_2
XFILLER_42_630 VGND VGND VPWR VPWR sky130_fd_sc_hd__decap_3
XFILLER_61_438 VGND VGND VPWR VPWR sky130_fd_sc_hd__decap_3
XTAP_TAPCELL_ROW_103_1414 VGND VPWR sky130_fd_sc_hd__tapvpwrvgnd_1
XFILLER_26_192 VGND VGND VPWR VPWR sky130_fd_sc_hd__decap_3
XFILLER_41_184 VGND VGND VPWR VPWR sky130_fd_sc_hd__decap_3
XFILLER_41_195 VGND VGND VPWR VPWR sky130_fd_sc_hd__decap_3
XFILLER_10_571 VGND VGND VPWR VPWR sky130_fd_sc_hd__decap_3
XFILLER_6_575 VGND VGND VPWR VPWR sky130_fd_sc_hd__decap_3
XFILLER_69_516 VGND VGND VPWR VPWR sky130_fd_sc_hd__decap_3
XFILLER_96_302 VGND VGND VPWR VPWR sky130_fd_sc_hd__decap_3
XPHY_EDGE_ROW_10_Right_10 VGND VGND VPWR VPWR sky130_fd_sc_hd__decap_3
XFILLER_96_368 VGND VGND VPWR VPWR sky130_fd_sc_hd__decap_3
XFILLER_37_435 VGND VGND VPWR VPWR sky130_fd_sc_hd__decap_3
XTAP_TAPCELL_ROW_69_1033 VGND VPWR sky130_fd_sc_hd__tapvpwrvgnd_1
XFILLER_37_468 VGND VGND VPWR VPWR sky130_fd_sc_hd__decap_3
XFILLER_64_276 VGND VGND VPWR VPWR sky130_fd_sc_hd__decap_3
XFILLER_24_118 VGND VGND VPWR VPWR sky130_fd_sc_hd__decap_3
XFILLER_52_427 VGND VGND VPWR VPWR sky130_fd_sc_hd__decap_3
XFILLER_52_449 VGND VGND VPWR VPWR sky130_fd_sc_hd__decap_3
Xclkbuf_leaf_44_clk clkbuf_leaf_2_clk/A VGND VGND VPWR VPWR clkload6/A sky130_fd_sc_hd__clkbuf_16
X_4932_ _5092_/C _4927_/X _4929_/Y _6996_/D _5666_/A VGND VGND VPWR VPWR _4932_/X
+ sky130_fd_sc_hd__a32o_2
XTAP_TAPCELL_ROW_63_956 VGND VPWR sky130_fd_sc_hd__tapvpwrvgnd_1
XTAP_TAPCELL_ROW_35_636 VGND VPWR sky130_fd_sc_hd__tapvpwrvgnd_1
XFILLER_17_192 VGND VGND VPWR VPWR sky130_fd_sc_hd__decap_3
XFILLER_33_641 VGND VGND VPWR VPWR sky130_fd_sc_hd__decap_3
X_6602_ _6602_/A VGND VGND VPWR VPWR _6602_/Y sky130_fd_sc_hd__inv_2
XFILLER_32_184 VGND VGND VPWR VPWR sky130_fd_sc_hd__decap_3
X_3814_ _3814_/A1 _3857_/A2 _3813_/Y VGND VGND VPWR VPWR _7391_/D sky130_fd_sc_hd__a21bo_2
XFILLER_20_368 VGND VGND VPWR VPWR sky130_fd_sc_hd__decap_3
X_6533_ _6630_/A VGND VGND VPWR VPWR _6533_/Y sky130_fd_sc_hd__inv_2
X_3745_ _6978_/Q _3853_/A2 _3925_/B1 _6723_/Q _3744_/X VGND VGND VPWR VPWR _3745_/X
+ sky130_fd_sc_hd__a221o_2
X_6464_ _6625_/A VGND VGND VPWR VPWR _6464_/Y sky130_fd_sc_hd__inv_2
XFILLER_9_380 VGND VGND VPWR VPWR sky130_fd_sc_hd__decap_3
X_5415_ _5415_/A0 _5121_/X _5429_/S VGND VGND VPWR VPWR _7126_/D sky130_fd_sc_hd__mux2_2
X_3676_ _6716_/Q VGND VGND VPWR VPWR _3676_/Y sky130_fd_sc_hd__inv_2
X_6395_ _6557_/A VGND VGND VPWR VPWR _6395_/Y sky130_fd_sc_hd__inv_2
XFILLER_87_302 VGND VGND VPWR VPWR sky130_fd_sc_hd__decap_3
X_5346_ _5346_/A0 _5121_/X _7412_/A VGND VGND VPWR VPWR _7158_/D sky130_fd_sc_hd__mux2_2
XTAP_TAPCELL_ROW_7_317 VGND VPWR sky130_fd_sc_hd__tapvpwrvgnd_1
XFILLER_99_140 VGND VGND VPWR VPWR sky130_fd_sc_hd__decap_3
XFILLER_102_624 VGND VGND VPWR VPWR sky130_fd_sc_hd__decap_3
XFILLER_87_346 VGND VGND VPWR VPWR sky130_fd_sc_hd__decap_3
XFILLER_87_379 VGND VGND VPWR VPWR sky130_fd_sc_hd__decap_3
X_7016_ _7357_/CLK _7016_/D _6296_/Y VGND VGND VPWR VPWR _7016_/Q sky130_fd_sc_hd__dfrtp_2
X_4228_ _7014_/Q _4601_/S _4414_/B1 _7195_/Q _4227_/X VGND VGND VPWR VPWR _4228_/X
+ sky130_fd_sc_hd__a221o_2
XFILLER_101_178 VGND VGND VPWR VPWR sky130_fd_sc_hd__decap_3
XFILLER_101_189 VGND VGND VPWR VPWR sky130_fd_sc_hd__decap_3
XFILLER_68_560 VGND VGND VPWR VPWR sky130_fd_sc_hd__decap_3
XFILLER_28_435 VGND VGND VPWR VPWR sky130_fd_sc_hd__decap_3
XFILLER_28_446 VGND VGND VPWR VPWR sky130_fd_sc_hd__decap_3
XFILLER_95_390 VGND VGND VPWR VPWR sky130_fd_sc_hd__fill_2
X_4159_ _7329_/Q _3958_/S _4261_/A2 _7361_/Q _4347_/C1 VGND VGND VPWR VPWR _4159_/X
+ sky130_fd_sc_hd__a221o_2
XPHY_EDGE_ROW_106_Right_106 VGND VGND VPWR VPWR sky130_fd_sc_hd__decap_3
XFILLER_102_21 VGND VGND VPWR VPWR sky130_fd_sc_hd__decap_3
XFILLER_16_619 VGND VGND VPWR VPWR sky130_fd_sc_hd__decap_3
XFILLER_102_32 VGND VGND VPWR VPWR sky130_fd_sc_hd__decap_3
XFILLER_62_25 VGND VGND VPWR VPWR sky130_fd_sc_hd__decap_3
XFILLER_70_268 VGND VGND VPWR VPWR sky130_fd_sc_hd__fill_1
Xclkbuf_leaf_35_clk clkbuf_3_2__f_clk/X VGND VGND VPWR VPWR _7348_/CLK sky130_fd_sc_hd__clkbuf_16
XFILLER_11_302 VGND VGND VPWR VPWR sky130_fd_sc_hd__decap_3
XFILLER_23_162 VGND VGND VPWR VPWR sky130_fd_sc_hd__decap_3
XFILLER_11_335 VGND VGND VPWR VPWR sky130_fd_sc_hd__fill_1
XFILLER_11_346 VGND VGND VPWR VPWR sky130_fd_sc_hd__decap_3
XFILLER_23_184 VGND VGND VPWR VPWR sky130_fd_sc_hd__decap_3
XFILLER_7_328 VGND VGND VPWR VPWR sky130_fd_sc_hd__decap_3
XPHY_EDGE_ROW_12_Left_121 VGND VGND VPWR VPWR sky130_fd_sc_hd__decap_3
XFILLER_3_556 VGND VGND VPWR VPWR sky130_fd_sc_hd__decap_3
XFILLER_3_567 VGND VGND VPWR VPWR sky130_fd_sc_hd__decap_3
XFILLER_105_473 VGND VGND VPWR VPWR sky130_fd_sc_hd__decap_3
XFILLER_78_346 VGND VGND VPWR VPWR sky130_fd_sc_hd__fill_2
XPHY_EDGE_ROW_21_Left_130 VGND VGND VPWR VPWR sky130_fd_sc_hd__decap_3
XFILLER_19_435 VGND VGND VPWR VPWR sky130_fd_sc_hd__decap_3
XFILLER_93_349 VGND VGND VPWR VPWR sky130_fd_sc_hd__decap_3
XFILLER_34_405 VGND VGND VPWR VPWR sky130_fd_sc_hd__decap_3
XFILLER_46_265 VGND VGND VPWR VPWR sky130_fd_sc_hd__decap_3
XFILLER_74_574 VGND VGND VPWR VPWR sky130_fd_sc_hd__fill_1
XFILLER_34_427 VGND VGND VPWR VPWR sky130_fd_sc_hd__fill_2
XFILLER_34_438 VGND VGND VPWR VPWR sky130_fd_sc_hd__fill_1
XFILLER_36_81 VGND VGND VPWR VPWR sky130_fd_sc_hd__decap_3
XFILLER_15_641 VGND VGND VPWR VPWR sky130_fd_sc_hd__decap_3
Xclkbuf_leaf_26_clk clkbuf_3_6__f_clk/X VGND VGND VPWR VPWR _7366_/CLK sky130_fd_sc_hd__clkbuf_16
XTAP_TAPCELL_ROW_32_606 VGND VPWR sky130_fd_sc_hd__tapvpwrvgnd_1
XFILLER_30_622 VGND VGND VPWR VPWR sky130_fd_sc_hd__decap_3
XFILLER_42_471 VGND VGND VPWR VPWR sky130_fd_sc_hd__decap_3
XFILLER_61_279 VGND VGND VPWR VPWR sky130_fd_sc_hd__fill_1
XTAP_TAPCELL_ROW_60_926 VGND VPWR sky130_fd_sc_hd__tapvpwrvgnd_1
XFILLER_14_184 VGND VGND VPWR VPWR sky130_fd_sc_hd__decap_3
XFILLER_52_91 VGND VGND VPWR VPWR sky130_fd_sc_hd__decap_3
XTAP_TAPCELL_ROW_40_694 VGND VPWR sky130_fd_sc_hd__tapvpwrvgnd_1
XTAP_TAPCELL_ROW_12_374 VGND VPWR sky130_fd_sc_hd__tapvpwrvgnd_1
XFILLER_6_361 VGND VGND VPWR VPWR sky130_fd_sc_hd__decap_3
Xhold807 _6908_/Q VGND VGND VPWR VPWR _6908_/D sky130_fd_sc_hd__dlygate4sd3_1
Xhold818 _6809_/Q VGND VGND VPWR VPWR _6809_/D sky130_fd_sc_hd__dlygate4sd3_1
XFILLER_6_394 VGND VGND VPWR VPWR sky130_fd_sc_hd__decap_3
Xhold829 _6805_/Q VGND VGND VPWR VPWR _6805_/D sky130_fd_sc_hd__dlygate4sd3_1
X_3461_ _7281_/Q _4532_/S _3366_/X _7153_/Q _3460_/X VGND VGND VPWR VPWR _3461_/X
+ sky130_fd_sc_hd__a221o_2
XFILLER_42_3 VGND VGND VPWR VPWR sky130_fd_sc_hd__fill_1
X_5200_ _5200_/A _5207_/B VGND VGND VPWR VPWR _7228_/D sky130_fd_sc_hd__and2_2
X_3392_ _3429_/A _3429_/B VGND VGND VPWR VPWR _3586_/A sky130_fd_sc_hd__nor2_2
XFILLER_97_600 VGND VGND VPWR VPWR sky130_fd_sc_hd__decap_3
XFILLER_69_324 VGND VGND VPWR VPWR sky130_fd_sc_hd__decap_3
XFILLER_69_335 VGND VGND VPWR VPWR sky130_fd_sc_hd__fill_1
X_5131_ _3992_/Y _5128_/Y _6982_/D _5156_/S VGND VGND VPWR VPWR _5131_/X sky130_fd_sc_hd__o22a_2
XTAP_TAPCELL_ROW_75_1092 VGND VPWR sky130_fd_sc_hd__tapvpwrvgnd_1
XFILLER_96_110 VGND VGND VPWR VPWR sky130_fd_sc_hd__decap_3
XFILLER_96_132 VGND VGND VPWR VPWR sky130_fd_sc_hd__decap_3
XFILLER_69_379 VGND VGND VPWR VPWR sky130_fd_sc_hd__decap_3
XFILLER_84_327 VGND VGND VPWR VPWR sky130_fd_sc_hd__decap_3
XFILLER_96_176 VGND VGND VPWR VPWR sky130_fd_sc_hd__decap_3
XFILLER_37_221 VGND VGND VPWR VPWR sky130_fd_sc_hd__decap_3
XFILLER_37_243 VGND VGND VPWR VPWR sky130_fd_sc_hd__decap_3
XFILLER_37_265 VGND VGND VPWR VPWR sky130_fd_sc_hd__decap_3
XFILLER_37_276 VGND VGND VPWR VPWR sky130_fd_sc_hd__fill_1
XFILLER_25_427 VGND VGND VPWR VPWR sky130_fd_sc_hd__decap_3
XFILLER_25_449 VGND VGND VPWR VPWR sky130_fd_sc_hd__decap_3
XFILLER_37_287 VGND VGND VPWR VPWR sky130_fd_sc_hd__fill_2
XFILLER_52_213 VGND VGND VPWR VPWR sky130_fd_sc_hd__decap_3
XFILLER_80_511 VGND VGND VPWR VPWR sky130_fd_sc_hd__decap_3
XFILLER_80_533 VGND VGND VPWR VPWR sky130_fd_sc_hd__decap_3
XFILLER_92_371 VGND VGND VPWR VPWR sky130_fd_sc_hd__decap_3
XFILLER_92_393 VGND VGND VPWR VPWR sky130_fd_sc_hd__fill_2
XTAP_TAPCELL_ROW_48_783 VGND VPWR sky130_fd_sc_hd__tapvpwrvgnd_1
XFILLER_80_577 VGND VGND VPWR VPWR sky130_fd_sc_hd__fill_1
Xclkbuf_leaf_17_clk clkload1/A VGND VGND VPWR VPWR _7406_/CLK sky130_fd_sc_hd__clkbuf_16
XFILLER_21_611 VGND VGND VPWR VPWR sky130_fd_sc_hd__decap_3
XFILLER_33_482 VGND VGND VPWR VPWR sky130_fd_sc_hd__decap_3
XFILLER_21_644 VGND VGND VPWR VPWR sky130_fd_sc_hd__decap_3
X_4846_ _4903_/A _4890_/B VGND VGND VPWR VPWR _4884_/A sky130_fd_sc_hd__nand2_2
X_6516_ _6646_/A VGND VGND VPWR VPWR _6516_/Y sky130_fd_sc_hd__inv_2
X_4777_ _4777_/A _4777_/B _4777_/C VGND VGND VPWR VPWR _4777_/X sky130_fd_sc_hd__and3_2
XFILLER_4_309 VGND VGND VPWR VPWR sky130_fd_sc_hd__decap_3
X_3728_ _3746_/A _3728_/B VGND VGND VPWR VPWR _3728_/Y sky130_fd_sc_hd__nor2_2
X_6447_ _6541_/A VGND VGND VPWR VPWR _6447_/Y sky130_fd_sc_hd__inv_2
X_6378_ _6601_/A VGND VGND VPWR VPWR _6378_/Y sky130_fd_sc_hd__inv_2
XFILLER_102_410 VGND VGND VPWR VPWR sky130_fd_sc_hd__decap_3
XFILLER_102_421 VGND VGND VPWR VPWR sky130_fd_sc_hd__decap_3
X_5329_ _5329_/A0 _4997_/X _5333_/S VGND VGND VPWR VPWR _7166_/D sky130_fd_sc_hd__mux2_2
XFILLER_0_548 VGND VGND VPWR VPWR sky130_fd_sc_hd__fill_1
XFILLER_102_454 VGND VGND VPWR VPWR sky130_fd_sc_hd__decap_3
XFILLER_87_143 VGND VGND VPWR VPWR sky130_fd_sc_hd__decap_3
XFILLER_102_487 VGND VGND VPWR VPWR sky130_fd_sc_hd__decap_3
XFILLER_48_519 VGND VGND VPWR VPWR sky130_fd_sc_hd__decap_3
XFILLER_75_316 VGND VGND VPWR VPWR sky130_fd_sc_hd__decap_3
XFILLER_87_187 VGND VGND VPWR VPWR sky130_fd_sc_hd__decap_3
XFILLER_28_210 VGND VGND VPWR VPWR sky130_fd_sc_hd__decap_3
XFILLER_16_405 VGND VGND VPWR VPWR sky130_fd_sc_hd__decap_3
XFILLER_71_500 VGND VGND VPWR VPWR sky130_fd_sc_hd__decap_3
XFILLER_28_276 VGND VGND VPWR VPWR sky130_fd_sc_hd__decap_3
XFILLER_83_382 VGND VGND VPWR VPWR sky130_fd_sc_hd__decap_3
XFILLER_83_393 VGND VGND VPWR VPWR sky130_fd_sc_hd__decap_3
XFILLER_12_622 VGND VGND VPWR VPWR sky130_fd_sc_hd__decap_3
XFILLER_24_471 VGND VGND VPWR VPWR sky130_fd_sc_hd__decap_3
XFILLER_11_110 VGND VGND VPWR VPWR sky130_fd_sc_hd__fill_2
XFILLER_11_132 VGND VGND VPWR VPWR sky130_fd_sc_hd__decap_3
XFILLER_51_290 VGND VGND VPWR VPWR sky130_fd_sc_hd__decap_3
XFILLER_8_604 VGND VGND VPWR VPWR sky130_fd_sc_hd__decap_3
XFILLER_8_637 VGND VGND VPWR VPWR sky130_fd_sc_hd__decap_3
XFILLER_11_187 VGND VGND VPWR VPWR sky130_fd_sc_hd__decap_3
XFILLER_22_50 VGND VGND VPWR VPWR sky130_fd_sc_hd__fill_1
XFILLER_7_147 VGND VGND VPWR VPWR sky130_fd_sc_hd__decap_3
XFILLER_22_94 VGND VGND VPWR VPWR sky130_fd_sc_hd__decap_3
XFILLER_7_158 VGND VGND VPWR VPWR sky130_fd_sc_hd__decap_3
XFILLER_7_169 VGND VGND VPWR VPWR sky130_fd_sc_hd__decap_3
XFILLER_3_375 VGND VGND VPWR VPWR sky130_fd_sc_hd__decap_3
XFILLER_66_327 VGND VGND VPWR VPWR sky130_fd_sc_hd__decap_3
XFILLER_93_102 VGND VGND VPWR VPWR sky130_fd_sc_hd__decap_3
XFILLER_93_113 VGND VGND VPWR VPWR sky130_fd_sc_hd__decap_3
XFILLER_94_636 VGND VGND VPWR VPWR sky130_fd_sc_hd__decap_3
XFILLER_19_254 VGND VGND VPWR VPWR sky130_fd_sc_hd__decap_3
XFILLER_19_265 VGND VGND VPWR VPWR sky130_fd_sc_hd__decap_3
XFILLER_34_213 VGND VGND VPWR VPWR sky130_fd_sc_hd__decap_3
XFILLER_34_246 VGND VGND VPWR VPWR sky130_fd_sc_hd__decap_3
XTAP_TAPCELL_ROW_45_753 VGND VPWR sky130_fd_sc_hd__tapvpwrvgnd_1
XTAP_TAPCELL_ROW_17_433 VGND VPWR sky130_fd_sc_hd__tapvpwrvgnd_1
XFILLER_22_419 VGND VGND VPWR VPWR sky130_fd_sc_hd__fill_1
XFILLER_62_577 VGND VGND VPWR VPWR sky130_fd_sc_hd__fill_1
X_5680_ _7346_/Q hold907/X _5697_/S VGND VGND VPWR VPWR _6690_/D sky130_fd_sc_hd__mux2_2
X_4700_ _6988_/Q _5066_/A VGND VGND VPWR VPWR _5044_/A sky130_fd_sc_hd__and2_2
XFILLER_30_452 VGND VGND VPWR VPWR sky130_fd_sc_hd__fill_1
XFILLER_30_474 VGND VGND VPWR VPWR sky130_fd_sc_hd__fill_2
X_4631_ _5003_/A _4620_/C _4630_/X wire559/X VGND VGND VPWR VPWR _4631_/X sky130_fd_sc_hd__a31o_2
XFILLER_8_85 VGND VGND VPWR VPWR sky130_fd_sc_hd__decap_3
X_7350_ _7350_/CLK _7350_/D _6630_/Y VGND VGND VPWR VPWR _7350_/Q sky130_fd_sc_hd__dfrtp_2
XTAP_TAPCELL_ROW_77_1121 VGND VPWR sky130_fd_sc_hd__tapvpwrvgnd_1
X_7281_ _7350_/CLK _7281_/D _6561_/Y VGND VGND VPWR VPWR _7281_/Q sky130_fd_sc_hd__dfrtp_2
Xhold604 _6733_/Q VGND VGND VPWR VPWR _6733_/D sky130_fd_sc_hd__dlygate4sd3_1
Xhold615 _6725_/Q VGND VGND VPWR VPWR _6725_/D sky130_fd_sc_hd__dlygate4sd3_1
Xhold626 _6771_/Q VGND VGND VPWR VPWR _6771_/D sky130_fd_sc_hd__dlygate4sd3_1
X_6301_ _6612_/A VGND VGND VPWR VPWR _6301_/Y sky130_fd_sc_hd__inv_2
X_4493_ _4493_/A0 _7301_/Q _4501_/S VGND VGND VPWR VPWR _7333_/D sky130_fd_sc_hd__mux2_2
Xclkbuf_leaf_6_clk clkbuf_leaf_7_clk/A VGND VGND VPWR VPWR clkload9/A sky130_fd_sc_hd__clkbuf_16
Xhold637 _6961_/Q VGND VGND VPWR VPWR _6961_/D sky130_fd_sc_hd__dlygate4sd3_1
Xhold648 _6755_/Q VGND VGND VPWR VPWR _6755_/D sky130_fd_sc_hd__dlygate4sd3_1
Xhold659 _6959_/Q VGND VGND VPWR VPWR _6959_/D sky130_fd_sc_hd__dlygate4sd3_1
X_3375_ _5118_/A _3399_/B VGND VGND VPWR VPWR _5641_/A sky130_fd_sc_hd__nand2_2
XFILLER_97_452 VGND VGND VPWR VPWR sky130_fd_sc_hd__decap_3
XFILLER_57_316 VGND VGND VPWR VPWR sky130_fd_sc_hd__fill_2
XFILLER_69_165 VGND VGND VPWR VPWR sky130_fd_sc_hd__decap_3
X_5114_ _5114_/A _5114_/B VGND VGND VPWR VPWR _5114_/Y sky130_fd_sc_hd__nand2_2
XFILLER_97_485 VGND VGND VPWR VPWR sky130_fd_sc_hd__decap_3
XFILLER_85_647 VGND VGND VPWR VPWR sky130_fd_sc_hd__fill_1
X_5045_ _6988_/Q _5045_/B VGND VGND VPWR VPWR _5045_/X sky130_fd_sc_hd__or2_2
XFILLER_27_28 VGND VGND VPWR VPWR sky130_fd_sc_hd__fill_1
XFILLER_53_500 VGND VGND VPWR VPWR sky130_fd_sc_hd__decap_3
XFILLER_84_157 VGND VGND VPWR VPWR sky130_fd_sc_hd__decap_3
XTAP_TAPCELL_ROW_88_1250 VGND VPWR sky130_fd_sc_hd__tapvpwrvgnd_1
XFILLER_25_202 VGND VGND VPWR VPWR sky130_fd_sc_hd__decap_3
XFILLER_65_360 VGND VGND VPWR VPWR sky130_fd_sc_hd__decap_3
XFILLER_65_393 VGND VGND VPWR VPWR sky130_fd_sc_hd__decap_3
XFILLER_25_257 VGND VGND VPWR VPWR sky130_fd_sc_hd__decap_3
XFILLER_53_544 VGND VGND VPWR VPWR sky130_fd_sc_hd__decap_3
XFILLER_80_330 VGND VGND VPWR VPWR sky130_fd_sc_hd__decap_3
XFILLER_80_352 VGND VGND VPWR VPWR sky130_fd_sc_hd__decap_3
X_6996_ _7276_/CLK _6996_/D _6276_/Y VGND VGND VPWR VPWR _6996_/Q sky130_fd_sc_hd__dfrtp_2
XFILLER_13_419 VGND VGND VPWR VPWR sky130_fd_sc_hd__decap_3
XFILLER_25_268 VGND VGND VPWR VPWR sky130_fd_sc_hd__decap_3
XFILLER_53_599 VGND VGND VPWR VPWR sky130_fd_sc_hd__decap_3
XFILLER_40_249 VGND VGND VPWR VPWR sky130_fd_sc_hd__decap_3
XFILLER_21_452 VGND VGND VPWR VPWR sky130_fd_sc_hd__decap_3
X_4829_ _4948_/A _4829_/B VGND VGND VPWR VPWR _4829_/Y sky130_fd_sc_hd__nor2_2
XFILLER_5_629 VGND VGND VPWR VPWR sky130_fd_sc_hd__decap_3
XFILLER_4_139 VGND VGND VPWR VPWR sky130_fd_sc_hd__fill_1
XFILLER_108_53 VGND VGND VPWR VPWR sky130_fd_sc_hd__decap_3
XFILLER_0_389 VGND VGND VPWR VPWR sky130_fd_sc_hd__decap_3
XFILLER_102_251 VGND VGND VPWR VPWR sky130_fd_sc_hd__fill_1
XFILLER_48_305 VGND VGND VPWR VPWR sky130_fd_sc_hd__decap_3
XFILLER_76_603 VGND VGND VPWR VPWR sky130_fd_sc_hd__fill_2
XFILLER_88_463 VGND VGND VPWR VPWR sky130_fd_sc_hd__fill_2
XFILLER_88_485 VGND VGND VPWR VPWR sky130_fd_sc_hd__decap_3
XFILLER_48_338 VGND VGND VPWR VPWR sky130_fd_sc_hd__decap_3
XFILLER_75_113 VGND VGND VPWR VPWR sky130_fd_sc_hd__fill_2
XFILLER_88_496 VGND VGND VPWR VPWR sky130_fd_sc_hd__decap_3
XFILLER_91_617 VGND VGND VPWR VPWR sky130_fd_sc_hd__fill_2
XFILLER_16_213 VGND VGND VPWR VPWR sky130_fd_sc_hd__decap_3
XFILLER_29_596 VGND VGND VPWR VPWR sky130_fd_sc_hd__decap_3
XFILLER_56_371 VGND VGND VPWR VPWR sky130_fd_sc_hd__decap_3
XFILLER_90_105 VGND VGND VPWR VPWR sky130_fd_sc_hd__decap_3
XFILLER_91_639 VGND VGND VPWR VPWR sky130_fd_sc_hd__decap_3
Xplace319 _4422_/A2 VGND VGND VPWR VPWR _4437_/A2 sky130_fd_sc_hd__buf_2
Xplace308 _3548_/X VGND VGND VPWR VPWR _4948_/A sky130_fd_sc_hd__buf_2
XFILLER_17_72 VGND VGND VPWR VPWR sky130_fd_sc_hd__fill_1
XFILLER_44_544 VGND VGND VPWR VPWR sky130_fd_sc_hd__decap_3
XFILLER_83_190 VGND VGND VPWR VPWR sky130_fd_sc_hd__decap_3
XFILLER_17_94 VGND VGND VPWR VPWR sky130_fd_sc_hd__decap_3
XFILLER_31_216 VGND VGND VPWR VPWR sky130_fd_sc_hd__decap_3
XFILLER_71_374 VGND VGND VPWR VPWR sky130_fd_sc_hd__decap_3
XTAP_TAPCELL_ROW_42_712 VGND VPWR sky130_fd_sc_hd__tapvpwrvgnd_1
XTAP_TAPCELL_ROW_42_723 VGND VPWR sky130_fd_sc_hd__tapvpwrvgnd_1
XFILLER_12_441 VGND VGND VPWR VPWR sky130_fd_sc_hd__decap_3
XFILLER_33_60 VGND VGND VPWR VPWR sky130_fd_sc_hd__fill_2
XFILLER_8_412 VGND VGND VPWR VPWR sky130_fd_sc_hd__decap_3
XFILLER_8_467 VGND VGND VPWR VPWR sky130_fd_sc_hd__decap_3
XFILLER_8_489 VGND VGND VPWR VPWR sky130_fd_sc_hd__decap_3
XTAP_TAPCELL_ROW_22_491 VGND VPWR sky130_fd_sc_hd__tapvpwrvgnd_1
XFILLER_4_640 VGND VGND VPWR VPWR sky130_fd_sc_hd__decap_3
XFILLER_3_161 VGND VGND VPWR VPWR sky130_fd_sc_hd__decap_3
XFILLER_3_172 VGND VGND VPWR VPWR sky130_fd_sc_hd__decap_3
XFILLER_98_227 VGND VGND VPWR VPWR sky130_fd_sc_hd__decap_3
XFILLER_79_441 VGND VGND VPWR VPWR sky130_fd_sc_hd__fill_2
XFILLER_79_452 VGND VGND VPWR VPWR sky130_fd_sc_hd__decap_3
XFILLER_98_249 VGND VGND VPWR VPWR sky130_fd_sc_hd__decap_3
XFILLER_67_603 VGND VGND VPWR VPWR sky130_fd_sc_hd__decap_3
XFILLER_67_625 VGND VGND VPWR VPWR sky130_fd_sc_hd__decap_3
XFILLER_79_485 VGND VGND VPWR VPWR sky130_fd_sc_hd__fill_1
XFILLER_94_411 VGND VGND VPWR VPWR sky130_fd_sc_hd__fill_2
XTAP_TAPCELL_ROW_72_1062 VGND VPWR sky130_fd_sc_hd__tapvpwrvgnd_1
XFILLER_94_477 VGND VGND VPWR VPWR sky130_fd_sc_hd__decap_3
XFILLER_81_105 VGND VGND VPWR VPWR sky130_fd_sc_hd__decap_3
XFILLER_81_138 VGND VGND VPWR VPWR sky130_fd_sc_hd__decap_3
XFILLER_94_499 VGND VGND VPWR VPWR sky130_fd_sc_hd__decap_3
XFILLER_62_341 VGND VGND VPWR VPWR sky130_fd_sc_hd__decap_3
X_6850_ clkload7/A _6850_/D VGND VGND VPWR VPWR _6850_/Q sky130_fd_sc_hd__dfxtp_2
XFILLER_62_385 VGND VGND VPWR VPWR sky130_fd_sc_hd__fill_1
X_6781_ clkload3/A _6781_/D VGND VGND VPWR VPWR _6781_/Q sky130_fd_sc_hd__dfxtp_2
XPHY_EDGE_ROW_8_Right_8 VGND VGND VPWR VPWR sky130_fd_sc_hd__decap_3
XFILLER_50_547 VGND VGND VPWR VPWR sky130_fd_sc_hd__decap_3
X_3993_ _4467_/B _3919_/X _3991_/X _3992_/Y VGND VGND VPWR VPWR _3993_/X sky130_fd_sc_hd__a31o_2
XTAP_TAPCELL_ROW_83_1191 VGND VPWR sky130_fd_sc_hd__tapvpwrvgnd_1
X_5663_ _5663_/A _5663_/B _5663_/C _5663_/D VGND VGND VPWR VPWR _5664_/D sky130_fd_sc_hd__nor4_2
X_7402_ _7406_/CLK _7402_/D _6682_/Y VGND VGND VPWR VPWR _7402_/Q sky130_fd_sc_hd__dfrtp_2
X_4614_ _4614_/A _4614_/B _4614_/C _5113_/A VGND VGND VPWR VPWR _4614_/X sky130_fd_sc_hd__and4_4
X_7333_ _7366_/CLK _7333_/D _6613_/Y VGND VGND VPWR VPWR _7333_/Q sky130_fd_sc_hd__dfrtp_2
XFILLER_1_109 VGND VGND VPWR VPWR sky130_fd_sc_hd__decap_3
X_7264_ _7357_/CLK _7264_/D _6544_/Y VGND VGND VPWR VPWR _7264_/Q sky130_fd_sc_hd__dfrtp_2
X_4476_ _4476_/A0 _7309_/Q _4478_/S VGND VGND VPWR VPWR _7341_/D sky130_fd_sc_hd__mux2_2
X_7195_ _7387_/CLK _7195_/D _6475_/Y VGND VGND VPWR VPWR _7195_/Q sky130_fd_sc_hd__dfrtp_2
X_3427_ _3527_/A _3427_/B VGND VGND VPWR VPWR _3508_/A sky130_fd_sc_hd__nand2b_2
XPHY_EDGE_ROW_39_Right_39 VGND VGND VPWR VPWR sky130_fd_sc_hd__decap_3
XFILLER_57_102 VGND VGND VPWR VPWR sky130_fd_sc_hd__decap_3
XFILLER_58_625 VGND VGND VPWR VPWR sky130_fd_sc_hd__decap_3
X_3358_ _4217_/A1 _3469_/B _3449_/A _3365_/A VGND VGND VPWR VPWR _4599_/S sky130_fd_sc_hd__o211a_4
XFILLER_38_38 VGND VGND VPWR VPWR sky130_fd_sc_hd__fill_1
XFILLER_57_113 VGND VGND VPWR VPWR sky130_fd_sc_hd__decap_3
XFILLER_85_433 VGND VGND VPWR VPWR sky130_fd_sc_hd__decap_3
XFILLER_85_444 VGND VGND VPWR VPWR sky130_fd_sc_hd__decap_3
Xhold1101 _7230_/Q VGND VGND VPWR VPWR _5196_/A sky130_fd_sc_hd__dlygate4sd3_1
Xhold1112 _7322_/Q VGND VGND VPWR VPWR _4515_/A0 sky130_fd_sc_hd__dlygate4sd3_1
Xhold1123 _7132_/Q VGND VGND VPWR VPWR _5402_/A0 sky130_fd_sc_hd__dlygate4sd3_1
XFILLER_57_157 VGND VGND VPWR VPWR sky130_fd_sc_hd__decap_3
XFILLER_73_617 VGND VGND VPWR VPWR sky130_fd_sc_hd__fill_2
XFILLER_85_455 VGND VGND VPWR VPWR sky130_fd_sc_hd__decap_3
Xhold1134 _7152_/Q VGND VGND VPWR VPWR _5358_/A0 sky130_fd_sc_hd__dlygate4sd3_1
Xhold1145 _7150_/Q VGND VGND VPWR VPWR _5365_/A0 sky130_fd_sc_hd__dlygate4sd3_1
Xhold1156 _7167_/Q VGND VGND VPWR VPWR _5327_/A0 sky130_fd_sc_hd__dlygate4sd3_1
Xhold1167 _7231_/Q VGND VGND VPWR VPWR _5194_/A sky130_fd_sc_hd__dlygate4sd3_1
XFILLER_26_511 VGND VGND VPWR VPWR sky130_fd_sc_hd__decap_3
XFILLER_38_382 VGND VGND VPWR VPWR sky130_fd_sc_hd__decap_3
XFILLER_72_116 VGND VGND VPWR VPWR sky130_fd_sc_hd__decap_3
XFILLER_73_639 VGND VGND VPWR VPWR sky130_fd_sc_hd__decap_3
Xhold1178 _7156_/Q VGND VGND VPWR VPWR _5350_/A0 sky130_fd_sc_hd__dlygate4sd3_1
Xhold1189 _7147_/Q VGND VGND VPWR VPWR _5371_/A0 sky130_fd_sc_hd__dlygate4sd3_1
X_5028_ _5028_/A0 _5027_/X _5159_/S VGND VGND VPWR VPWR _7260_/D sky130_fd_sc_hd__mux2_2
XFILLER_54_26 VGND VGND VPWR VPWR sky130_fd_sc_hd__fill_2
XFILLER_54_48 VGND VGND VPWR VPWR sky130_fd_sc_hd__fill_1
XFILLER_65_190 VGND VGND VPWR VPWR sky130_fd_sc_hd__decap_3
XFILLER_13_216 VGND VGND VPWR VPWR sky130_fd_sc_hd__decap_3
XFILLER_26_599 VGND VGND VPWR VPWR sky130_fd_sc_hd__decap_3
XFILLER_53_363 VGND VGND VPWR VPWR sky130_fd_sc_hd__fill_2
XFILLER_80_160 VGND VGND VPWR VPWR sky130_fd_sc_hd__decap_3
XFILLER_41_536 VGND VGND VPWR VPWR sky130_fd_sc_hd__decap_3
XFILLER_53_396 VGND VGND VPWR VPWR sky130_fd_sc_hd__decap_3
XFILLER_80_193 VGND VGND VPWR VPWR sky130_fd_sc_hd__decap_3
X_6979_ _7383_/CLK _6979_/D _6259_/Y VGND VGND VPWR VPWR _6979_/Q sky130_fd_sc_hd__dfrtp_2
XPHY_EDGE_ROW_48_Right_48 VGND VGND VPWR VPWR sky130_fd_sc_hd__decap_3
XFILLER_21_271 VGND VGND VPWR VPWR sky130_fd_sc_hd__decap_3
XFILLER_21_293 VGND VGND VPWR VPWR sky130_fd_sc_hd__decap_3
XFILLER_5_437 VGND VGND VPWR VPWR sky130_fd_sc_hd__fill_2
XTAP_TAPCELL_ROW_97_1349 VGND VPWR sky130_fd_sc_hd__tapvpwrvgnd_1
XFILLER_5_459 VGND VGND VPWR VPWR sky130_fd_sc_hd__fill_1
XPHY_EDGE_ROW_57_Right_57 VGND VGND VPWR VPWR sky130_fd_sc_hd__decap_3
Xhold990 _7198_/Q VGND VGND VPWR VPWR hold990/X sky130_fd_sc_hd__dlygate4sd3_1
XFILLER_95_219 VGND VGND VPWR VPWR sky130_fd_sc_hd__decap_3
XFILLER_0_164 VGND VGND VPWR VPWR sky130_fd_sc_hd__decap_3
XFILLER_0_186 VGND VGND VPWR VPWR sky130_fd_sc_hd__fill_2
XFILLER_49_647 VGND VGND VPWR VPWR sky130_fd_sc_hd__fill_1
XFILLER_76_444 VGND VGND VPWR VPWR sky130_fd_sc_hd__decap_3
XFILLER_88_293 VGND VGND VPWR VPWR sky130_fd_sc_hd__fill_1
XFILLER_95_66 VGND VGND VPWR VPWR sky130_fd_sc_hd__decap_3
XFILLER_64_617 VGND VGND VPWR VPWR sky130_fd_sc_hd__decap_3
XFILLER_76_477 VGND VGND VPWR VPWR sky130_fd_sc_hd__decap_3
XFILLER_17_511 VGND VGND VPWR VPWR sky130_fd_sc_hd__decap_3
XFILLER_28_60 VGND VGND VPWR VPWR sky130_fd_sc_hd__decap_3
XFILLER_91_425 VGND VGND VPWR VPWR sky130_fd_sc_hd__decap_3
XFILLER_17_544 VGND VGND VPWR VPWR sky130_fd_sc_hd__decap_3
XFILLER_29_393 VGND VGND VPWR VPWR sky130_fd_sc_hd__fill_1
XFILLER_56_190 VGND VGND VPWR VPWR sky130_fd_sc_hd__decap_3
XFILLER_91_447 VGND VGND VPWR VPWR sky130_fd_sc_hd__fill_1
XFILLER_91_458 VGND VGND VPWR VPWR sky130_fd_sc_hd__decap_3
XFILLER_17_588 VGND VGND VPWR VPWR sky130_fd_sc_hd__decap_3
XFILLER_44_363 VGND VGND VPWR VPWR sky130_fd_sc_hd__fill_1
XTAP_TAPCELL_ROW_55_870 VGND VPWR sky130_fd_sc_hd__tapvpwrvgnd_1
XTAP_TAPCELL_ROW_27_550 VGND VPWR sky130_fd_sc_hd__tapvpwrvgnd_1
XTAP_TAPCELL_ROW_106_1456 VGND VPWR sky130_fd_sc_hd__tapvpwrvgnd_1
XPHY_EDGE_ROW_66_Right_66 VGND VGND VPWR VPWR sky130_fd_sc_hd__decap_3
XFILLER_44_396 VGND VGND VPWR VPWR sky130_fd_sc_hd__decap_3
XPHY_EDGE_ROW_4_Left_113 VGND VGND VPWR VPWR sky130_fd_sc_hd__decap_3
XFILLER_74_6 VGND VGND VPWR VPWR sky130_fd_sc_hd__decap_3
XFILLER_8_242 VGND VGND VPWR VPWR sky130_fd_sc_hd__decap_3
XFILLER_8_253 VGND VGND VPWR VPWR sky130_fd_sc_hd__decap_3
Xoutput517 _7009_/Q VGND VGND VPWR VPWR pc_out[0] sky130_fd_sc_hd__clkdlybuf4s25_1
Xoutput506 _5648_/A VGND VGND VPWR VPWR instruction_out[27] sky130_fd_sc_hd__clkdlybuf4s25_1
XPHY_EDGE_ROW_75_Right_75 VGND VGND VPWR VPWR sky130_fd_sc_hd__decap_3
Xoutput539 _5667_/A VGND VGND VPWR VPWR pc_out[2] sky130_fd_sc_hd__clkdlybuf4s25_1
Xoutput528 _7010_/Q VGND VGND VPWR VPWR pc_out[1] sky130_fd_sc_hd__clkdlybuf4s25_1
X_4330_ _5057_/B _4330_/B VGND VGND VPWR VPWR _4619_/B sky130_fd_sc_hd__or2_2
X_4261_ _7358_/Q _4261_/A2 _4261_/B1 _7166_/Q _4338_/C1 VGND VGND VPWR VPWR _4261_/X
+ sky130_fd_sc_hd__a221o_2
XFILLER_101_508 VGND VGND VPWR VPWR sky130_fd_sc_hd__decap_3
XFILLER_39_113 VGND VGND VPWR VPWR sky130_fd_sc_hd__decap_3
XFILLER_67_411 VGND VGND VPWR VPWR sky130_fd_sc_hd__decap_3
X_4192_ _4637_/B _4637_/C VGND VGND VPWR VPWR _4380_/A sky130_fd_sc_hd__and2_2
XFILLER_39_146 VGND VGND VPWR VPWR sky130_fd_sc_hd__decap_3
XFILLER_55_617 VGND VGND VPWR VPWR sky130_fd_sc_hd__decap_3
XFILLER_94_241 VGND VGND VPWR VPWR sky130_fd_sc_hd__decap_3
XFILLER_94_296 VGND VGND VPWR VPWR sky130_fd_sc_hd__decap_3
XPHY_EDGE_ROW_84_Right_84 VGND VGND VPWR VPWR sky130_fd_sc_hd__decap_3
XFILLER_54_138 VGND VGND VPWR VPWR sky130_fd_sc_hd__fill_2
XFILLER_82_469 VGND VGND VPWR VPWR sky130_fd_sc_hd__decap_3
X_6902_ _6974_/CLK _6902_/D VGND VGND VPWR VPWR _6902_/Q sky130_fd_sc_hd__dfxtp_2
X_6833_ _6958_/CLK _6833_/D VGND VGND VPWR VPWR _6833_/Q sky130_fd_sc_hd__dfxtp_2
XFILLER_35_385 VGND VGND VPWR VPWR sky130_fd_sc_hd__decap_3
XFILLER_62_193 VGND VGND VPWR VPWR sky130_fd_sc_hd__decap_3
XFILLER_90_480 VGND VGND VPWR VPWR sky130_fd_sc_hd__decap_3
XPHY_EDGE_ROW_59_Left_168 VGND VGND VPWR VPWR sky130_fd_sc_hd__decap_3
XFILLER_23_558 VGND VGND VPWR VPWR sky130_fd_sc_hd__fill_2
X_6764_ _6966_/CLK _6764_/D VGND VGND VPWR VPWR _6764_/Q sky130_fd_sc_hd__dfxtp_2
X_6695_ _7387_/CLK _6695_/D VGND VGND VPWR VPWR _6695_/Q sky130_fd_sc_hd__dfxtp_2
X_5715_ _7363_/Q hold916/X _5737_/S VGND VGND VPWR VPWR _6707_/D sky130_fd_sc_hd__mux2_2
X_5646_ _5646_/A VGND VGND VPWR VPWR _5646_/Y sky130_fd_sc_hd__inv_2
XPHY_EDGE_ROW_93_Right_93 VGND VGND VPWR VPWR sky130_fd_sc_hd__decap_3
X_5577_ _5577_/A0 _5038_/X _5581_/S VGND VGND VPWR VPWR _7040_/D sky130_fd_sc_hd__mux2_2
X_7316_ _7348_/CLK _7316_/D _6596_/Y VGND VGND VPWR VPWR _7316_/Q sky130_fd_sc_hd__dfrtp_2
X_4528_ _4528_/A _4528_/B VGND VGND VPWR VPWR _7315_/D sky130_fd_sc_hd__or2_2
X_7247_ _7376_/CLK _7247_/D _6527_/Y VGND VGND VPWR VPWR _7247_/Q sky130_fd_sc_hd__dfrtp_2
X_4459_ _4040_/Y _4457_/X _4458_/X _4459_/C1 VGND VGND VPWR VPWR _5655_/B sky130_fd_sc_hd__o211a_2
XPHY_EDGE_ROW_68_Left_177 VGND VGND VPWR VPWR sky130_fd_sc_hd__decap_3
XFILLER_58_400 VGND VGND VPWR VPWR sky130_fd_sc_hd__decap_3
XFILLER_105_32 VGND VGND VPWR VPWR sky130_fd_sc_hd__decap_3
X_7178_ _7276_/CLK _7178_/D _6458_/Y VGND VGND VPWR VPWR _7178_/Q sky130_fd_sc_hd__dfrtp_2
XFILLER_46_617 VGND VGND VPWR VPWR sky130_fd_sc_hd__decap_3
XTAP_TAPCELL_ROW_5_289 VGND VPWR sky130_fd_sc_hd__tapvpwrvgnd_1
XFILLER_100_574 VGND VGND VPWR VPWR sky130_fd_sc_hd__decap_3
XFILLER_45_116 VGND VGND VPWR VPWR sky130_fd_sc_hd__decap_3
XFILLER_58_477 VGND VGND VPWR VPWR sky130_fd_sc_hd__decap_3
XFILLER_73_414 VGND VGND VPWR VPWR sky130_fd_sc_hd__decap_3
XFILLER_85_274 VGND VGND VPWR VPWR sky130_fd_sc_hd__decap_3
XFILLER_61_609 VGND VGND VPWR VPWR sky130_fd_sc_hd__decap_3
XFILLER_73_458 VGND VGND VPWR VPWR sky130_fd_sc_hd__decap_3
XFILLER_14_514 VGND VGND VPWR VPWR sky130_fd_sc_hd__decap_3
XFILLER_26_374 VGND VGND VPWR VPWR sky130_fd_sc_hd__decap_3
XPHY_EDGE_ROW_77_Left_186 VGND VGND VPWR VPWR sky130_fd_sc_hd__decap_3
XFILLER_14_525 VGND VGND VPWR VPWR sky130_fd_sc_hd__decap_3
XFILLER_26_385 VGND VGND VPWR VPWR sky130_fd_sc_hd__fill_1
XFILLER_53_193 VGND VGND VPWR VPWR sky130_fd_sc_hd__decap_3
XFILLER_81_35 VGND VGND VPWR VPWR sky130_fd_sc_hd__decap_3
XFILLER_81_491 VGND VGND VPWR VPWR sky130_fd_sc_hd__decap_3
XFILLER_41_366 VGND VGND VPWR VPWR sky130_fd_sc_hd__fill_2
XFILLER_81_57 VGND VGND VPWR VPWR sky130_fd_sc_hd__decap_3
XTAP_TAPCELL_ROW_101_1397 VGND VPWR sky130_fd_sc_hd__tapvpwrvgnd_1
XFILLER_5_223 VGND VGND VPWR VPWR sky130_fd_sc_hd__fill_1
XFILLER_5_245 VGND VGND VPWR VPWR sky130_fd_sc_hd__decap_3
XPHY_EDGE_ROW_86_Left_195 VGND VGND VPWR VPWR sky130_fd_sc_hd__decap_3
XFILLER_107_162 VGND VGND VPWR VPWR sky130_fd_sc_hd__decap_3
XFILLER_5_278 VGND VGND VPWR VPWR sky130_fd_sc_hd__fill_2
XFILLER_30_94 VGND VGND VPWR VPWR sky130_fd_sc_hd__decap_3
XFILLER_49_400 VGND VGND VPWR VPWR sky130_fd_sc_hd__decap_3
XFILLER_89_580 VGND VGND VPWR VPWR sky130_fd_sc_hd__decap_3
XFILLER_76_241 VGND VGND VPWR VPWR sky130_fd_sc_hd__decap_3
XFILLER_36_116 VGND VGND VPWR VPWR sky130_fd_sc_hd__decap_3
XFILLER_37_617 VGND VGND VPWR VPWR sky130_fd_sc_hd__decap_3
XFILLER_91_200 VGND VGND VPWR VPWR sky130_fd_sc_hd__decap_3
XFILLER_29_190 VGND VGND VPWR VPWR sky130_fd_sc_hd__decap_3
XFILLER_55_80 VGND VGND VPWR VPWR sky130_fd_sc_hd__decap_3
XFILLER_17_396 VGND VGND VPWR VPWR sky130_fd_sc_hd__decap_3
XFILLER_44_171 VGND VGND VPWR VPWR sky130_fd_sc_hd__decap_3
XFILLER_72_480 VGND VGND VPWR VPWR sky130_fd_sc_hd__decap_3
XFILLER_72_491 VGND VGND VPWR VPWR sky130_fd_sc_hd__decap_3
XFILLER_60_642 VGND VGND VPWR VPWR sky130_fd_sc_hd__fill_2
X_3830_ _6860_/Q _3883_/A2 _3884_/B1 _6852_/Q _3829_/X VGND VGND VPWR VPWR _3830_/X
+ sky130_fd_sc_hd__a221o_2
XFILLER_20_517 VGND VGND VPWR VPWR sky130_fd_sc_hd__fill_1
XTAP_TAPCELL_ROW_80_1150 VGND VPWR sky130_fd_sc_hd__tapvpwrvgnd_1
XFILLER_13_591 VGND VGND VPWR VPWR sky130_fd_sc_hd__decap_3
X_6480_ _6669_/A VGND VGND VPWR VPWR _6480_/Y sky130_fd_sc_hd__inv_2
X_3692_ _6715_/Q _3823_/A2 _3883_/B1 _6893_/Q _3691_/X VGND VGND VPWR VPWR _3692_/X
+ sky130_fd_sc_hd__a221o_2
XTAP_TAPCELL_ROW_30_578 VGND VPWR sky130_fd_sc_hd__tapvpwrvgnd_1
XFILLER_9_573 VGND VGND VPWR VPWR sky130_fd_sc_hd__decap_3
X_5362_ _3378_/A _5646_/A _5362_/C VGND VGND VPWR VPWR _5429_/S sky130_fd_sc_hd__and3b_2
XFILLER_99_311 VGND VGND VPWR VPWR sky130_fd_sc_hd__fill_2
X_7101_ _7280_/CLK _7101_/D _6381_/Y VGND VGND VPWR VPWR _7101_/Q sky130_fd_sc_hd__dfrtp_2
X_4313_ _4376_/A _4364_/A _4364_/B _4313_/D VGND VGND VPWR VPWR _4315_/A sky130_fd_sc_hd__or4_4
X_7032_ _7350_/CLK _7032_/D _6312_/Y VGND VGND VPWR VPWR _7032_/Q sky130_fd_sc_hd__dfrtp_2
X_4244_ _7293_/Q _4244_/B VGND VGND VPWR VPWR _4244_/X sky130_fd_sc_hd__and2_2
XFILLER_67_230 VGND VGND VPWR VPWR sky130_fd_sc_hd__decap_3
X_4175_ _7328_/Q _3975_/S _4347_/C1 _4174_/X VGND VGND VPWR VPWR _4175_/X sky130_fd_sc_hd__a211o_2
XFILLER_95_561 VGND VGND VPWR VPWR sky130_fd_sc_hd__decap_3
XFILLER_28_628 VGND VGND VPWR VPWR sky130_fd_sc_hd__decap_3
XFILLER_82_233 VGND VGND VPWR VPWR sky130_fd_sc_hd__decap_3
XTAP_TAPCELL_ROW_2_259 VGND VPWR sky130_fd_sc_hd__tapvpwrvgnd_1
XFILLER_82_277 VGND VGND VPWR VPWR sky130_fd_sc_hd__decap_3
XTAP_TAPCELL_ROW_66_998 VGND VPWR sky130_fd_sc_hd__tapvpwrvgnd_1
XTAP_TAPCELL_ROW_38_667 VGND VPWR sky130_fd_sc_hd__tapvpwrvgnd_1
XFILLER_23_300 VGND VGND VPWR VPWR sky130_fd_sc_hd__decap_3
XFILLER_35_182 VGND VGND VPWR VPWR sky130_fd_sc_hd__decap_3
XFILLER_51_620 VGND VGND VPWR VPWR sky130_fd_sc_hd__decap_3
XFILLER_50_130 VGND VGND VPWR VPWR sky130_fd_sc_hd__decap_3
XFILLER_50_141 VGND VGND VPWR VPWR sky130_fd_sc_hd__decap_3
X_6816_ _6976_/CLK _6816_/D VGND VGND VPWR VPWR _6816_/Q sky130_fd_sc_hd__dfxtp_2
XFILLER_23_399 VGND VGND VPWR VPWR sky130_fd_sc_hd__decap_3
XFILLER_50_185 VGND VGND VPWR VPWR sky130_fd_sc_hd__decap_3
X_6747_ clkload7/A _6747_/D VGND VGND VPWR VPWR _6747_/Q sky130_fd_sc_hd__dfxtp_2
X_6678_ _6678_/A VGND VGND VPWR VPWR _6678_/Y sky130_fd_sc_hd__inv_2
XTAP_TAPCELL_ROW_94_1319 VGND VPWR sky130_fd_sc_hd__tapvpwrvgnd_1
XFILLER_105_611 VGND VGND VPWR VPWR sky130_fd_sc_hd__decap_3
XFILLER_2_226 VGND VGND VPWR VPWR sky130_fd_sc_hd__decap_3
XFILLER_104_165 VGND VGND VPWR VPWR sky130_fd_sc_hd__decap_3
XFILLER_2_248 VGND VGND VPWR VPWR sky130_fd_sc_hd__decap_3
XFILLER_2_259 VGND VGND VPWR VPWR sky130_fd_sc_hd__decap_3
XFILLER_19_606 VGND VGND VPWR VPWR sky130_fd_sc_hd__decap_3
XFILLER_58_230 VGND VGND VPWR VPWR sky130_fd_sc_hd__decap_3
XFILLER_76_35 VGND VGND VPWR VPWR sky130_fd_sc_hd__decap_3
XFILLER_100_371 VGND VGND VPWR VPWR sky130_fd_sc_hd__fill_1
XFILLER_18_105 VGND VGND VPWR VPWR sky130_fd_sc_hd__decap_3
XFILLER_19_617 VGND VGND VPWR VPWR sky130_fd_sc_hd__decap_3
XFILLER_76_79 VGND VGND VPWR VPWR sky130_fd_sc_hd__decap_3
XFILLER_18_138 VGND VGND VPWR VPWR sky130_fd_sc_hd__fill_2
XFILLER_73_222 VGND VGND VPWR VPWR sky130_fd_sc_hd__fill_2
XFILLER_73_277 VGND VGND VPWR VPWR sky130_fd_sc_hd__decap_3
XFILLER_33_119 VGND VGND VPWR VPWR sky130_fd_sc_hd__fill_1
XFILLER_54_491 VGND VGND VPWR VPWR sky130_fd_sc_hd__fill_1
XFILLER_92_56 VGND VGND VPWR VPWR sky130_fd_sc_hd__fill_2
XTAP_TAPCELL_ROW_103_1415 VGND VPWR sky130_fd_sc_hd__tapvpwrvgnd_1
XFILLER_42_642 VGND VGND VPWR VPWR sky130_fd_sc_hd__fill_2
XFILLER_14_399 VGND VGND VPWR VPWR sky130_fd_sc_hd__decap_3
XPHY_EDGE_ROW_94_Left_203 VGND VGND VPWR VPWR sky130_fd_sc_hd__decap_3
XFILLER_10_583 VGND VGND VPWR VPWR sky130_fd_sc_hd__decap_3
XFILLER_6_554 VGND VGND VPWR VPWR sky130_fd_sc_hd__decap_3
XFILLER_6_587 VGND VGND VPWR VPWR sky130_fd_sc_hd__fill_1
XFILLER_6_598 VGND VGND VPWR VPWR sky130_fd_sc_hd__decap_3
XFILLER_69_539 VGND VGND VPWR VPWR sky130_fd_sc_hd__decap_3
XFILLER_1_281 VGND VGND VPWR VPWR sky130_fd_sc_hd__fill_1
XFILLER_49_274 VGND VGND VPWR VPWR sky130_fd_sc_hd__fill_1
XFILLER_77_561 VGND VGND VPWR VPWR sky130_fd_sc_hd__fill_1
XFILLER_37_425 VGND VGND VPWR VPWR sky130_fd_sc_hd__fill_1
XFILLER_64_211 VGND VGND VPWR VPWR sky130_fd_sc_hd__decap_3
XTAP_TAPCELL_ROW_69_1023 VGND VPWR sky130_fd_sc_hd__tapvpwrvgnd_1
XFILLER_25_609 VGND VGND VPWR VPWR sky130_fd_sc_hd__decap_3
XFILLER_92_553 VGND VGND VPWR VPWR sky130_fd_sc_hd__decap_3
XFILLER_92_586 VGND VGND VPWR VPWR sky130_fd_sc_hd__fill_2
XFILLER_33_620 VGND VGND VPWR VPWR sky130_fd_sc_hd__decap_3
X_4931_ _4931_/A _4931_/B VGND VGND VPWR VPWR _6996_/D sky130_fd_sc_hd__nor2_2
XTAP_TAPCELL_ROW_35_637 VGND VPWR sky130_fd_sc_hd__tapvpwrvgnd_1
XFILLER_32_141 VGND VGND VPWR VPWR sky130_fd_sc_hd__decap_3
X_4862_ _4825_/B _4862_/B VGND VGND VPWR VPWR _7000_/D sky130_fd_sc_hd__and2b_2
XTAP_TAPCELL_ROW_63_957 VGND VPWR sky130_fd_sc_hd__tapvpwrvgnd_1
XFILLER_32_152 VGND VGND VPWR VPWR sky130_fd_sc_hd__decap_3
X_6601_ _6601_/A VGND VGND VPWR VPWR _6601_/Y sky130_fd_sc_hd__inv_2
X_3813_ _3802_/X _3812_/X _3896_/B1 VGND VGND VPWR VPWR _3813_/Y sky130_fd_sc_hd__o21ai_2
X_4793_ _4793_/A0 _4792_/X _4946_/S VGND VGND VPWR VPWR _7274_/D sky130_fd_sc_hd__mux2_2
XFILLER_20_358 VGND VGND VPWR VPWR sky130_fd_sc_hd__decap_3
X_6532_ _6630_/A VGND VGND VPWR VPWR _6532_/Y sky130_fd_sc_hd__inv_2
X_3744_ _6728_/Q _3661_/X _3656_/Y _6973_/Q VGND VGND VPWR VPWR _3744_/X sky130_fd_sc_hd__a22o_2
X_6463_ _6463_/A VGND VGND VPWR VPWR _6463_/Y sky130_fd_sc_hd__inv_2
XFILLER_106_419 VGND VGND VPWR VPWR sky130_fd_sc_hd__fill_1
X_6394_ _6622_/A VGND VGND VPWR VPWR _6394_/Y sky130_fd_sc_hd__inv_2
XTAP_TAPCELL_ROW_7_318 VGND VPWR sky130_fd_sc_hd__tapvpwrvgnd_1
XFILLER_99_152 VGND VGND VPWR VPWR sky130_fd_sc_hd__decap_3
XFILLER_102_636 VGND VGND VPWR VPWR sky130_fd_sc_hd__decap_3
X_5276_ hold996/X _5094_/X _5276_/S VGND VGND VPWR VPWR _7192_/D sky130_fd_sc_hd__mux2_2
X_7015_ _7380_/CLK _7015_/D _6295_/Y VGND VGND VPWR VPWR _7015_/Q sky130_fd_sc_hd__dfrtp_2
X_4227_ _7355_/Q _4337_/B _4352_/B1 _7163_/Q VGND VGND VPWR VPWR _4227_/X sky130_fd_sc_hd__a22o_2
XFILLER_68_572 VGND VGND VPWR VPWR sky130_fd_sc_hd__decap_3
XFILLER_28_458 VGND VGND VPWR VPWR sky130_fd_sc_hd__decap_3
XFILLER_46_38 VGND VGND VPWR VPWR sky130_fd_sc_hd__fill_2
XFILLER_55_211 VGND VGND VPWR VPWR sky130_fd_sc_hd__decap_3
X_4158_ _4158_/A _4158_/B VGND VGND VPWR VPWR _4920_/A sky130_fd_sc_hd__nand2_2
XFILLER_55_244 VGND VGND VPWR VPWR sky130_fd_sc_hd__decap_3
XFILLER_83_564 VGND VGND VPWR VPWR sky130_fd_sc_hd__decap_3
X_4089_ _7206_/Q _3956_/S _4399_/A2 _7398_/Q VGND VGND VPWR VPWR _4089_/X sky130_fd_sc_hd__a22o_2
XFILLER_102_55 VGND VGND VPWR VPWR sky130_fd_sc_hd__fill_1
XFILLER_36_480 VGND VGND VPWR VPWR sky130_fd_sc_hd__decap_3
XFILLER_70_203 VGND VGND VPWR VPWR sky130_fd_sc_hd__fill_1
XFILLER_83_597 VGND VGND VPWR VPWR sky130_fd_sc_hd__fill_1
XFILLER_102_88 VGND VGND VPWR VPWR sky130_fd_sc_hd__decap_3
XFILLER_24_631 VGND VGND VPWR VPWR sky130_fd_sc_hd__decap_3
XFILLER_11_314 VGND VGND VPWR VPWR sky130_fd_sc_hd__decap_3
XFILLER_23_141 VGND VGND VPWR VPWR sky130_fd_sc_hd__decap_3
XFILLER_11_369 VGND VGND VPWR VPWR sky130_fd_sc_hd__decap_3
XFILLER_11_63 VGND VGND VPWR VPWR sky130_fd_sc_hd__decap_3
XFILLER_3_535 VGND VGND VPWR VPWR sky130_fd_sc_hd__decap_3
XFILLER_105_452 VGND VGND VPWR VPWR sky130_fd_sc_hd__fill_2
XFILLER_2_3 VGND VGND VPWR VPWR sky130_fd_sc_hd__decap_3
XFILLER_3_579 VGND VGND VPWR VPWR sky130_fd_sc_hd__decap_3
XFILLER_59_550 VGND VGND VPWR VPWR sky130_fd_sc_hd__fill_2
XFILLER_19_414 VGND VGND VPWR VPWR sky130_fd_sc_hd__decap_3
XFILLER_93_306 VGND VGND VPWR VPWR sky130_fd_sc_hd__decap_3
XFILLER_46_222 VGND VGND VPWR VPWR sky130_fd_sc_hd__decap_3
XFILLER_46_244 VGND VGND VPWR VPWR sky130_fd_sc_hd__decap_3
XFILLER_15_620 VGND VGND VPWR VPWR sky130_fd_sc_hd__decap_3
XFILLER_34_417 VGND VGND VPWR VPWR sky130_fd_sc_hd__decap_3
XFILLER_36_60 VGND VGND VPWR VPWR sky130_fd_sc_hd__fill_1
XFILLER_61_214 VGND VGND VPWR VPWR sky130_fd_sc_hd__fill_1
XFILLER_61_225 VGND VGND VPWR VPWR sky130_fd_sc_hd__decap_3
XFILLER_74_586 VGND VGND VPWR VPWR sky130_fd_sc_hd__fill_2
XFILLER_14_130 VGND VGND VPWR VPWR sky130_fd_sc_hd__decap_3
XFILLER_27_491 VGND VGND VPWR VPWR sky130_fd_sc_hd__decap_3
XFILLER_14_141 VGND VGND VPWR VPWR sky130_fd_sc_hd__decap_3
XFILLER_30_601 VGND VGND VPWR VPWR sky130_fd_sc_hd__decap_3
XTAP_TAPCELL_ROW_60_927 VGND VPWR sky130_fd_sc_hd__tapvpwrvgnd_1
XTAP_TAPCELL_ROW_32_607 VGND VPWR sky130_fd_sc_hd__tapvpwrvgnd_1
XFILLER_30_634 VGND VGND VPWR VPWR sky130_fd_sc_hd__decap_3
XFILLER_30_645 VGND VGND VPWR VPWR sky130_fd_sc_hd__decap_3
XFILLER_10_380 VGND VGND VPWR VPWR sky130_fd_sc_hd__decap_3
XTAP_TAPCELL_ROW_40_695 VGND VPWR sky130_fd_sc_hd__tapvpwrvgnd_1
XTAP_TAPCELL_ROW_12_375 VGND VPWR sky130_fd_sc_hd__tapvpwrvgnd_1
Xhold808 _6976_/Q VGND VGND VPWR VPWR _6976_/D sky130_fd_sc_hd__dlygate4sd3_1
Xhold819 _6943_/Q VGND VGND VPWR VPWR _6943_/D sky130_fd_sc_hd__dlygate4sd3_1
X_3460_ _7313_/Q _3996_/S _4346_/B1 _7345_/Q _4338_/C1 VGND VGND VPWR VPWR _3460_/X
+ sky130_fd_sc_hd__a221o_2
X_3391_ _7251_/Q _4599_/S _3390_/X VGND VGND VPWR VPWR _3589_/A sky130_fd_sc_hd__a21oi_2
XFILLER_35_3 VGND VGND VPWR VPWR sky130_fd_sc_hd__fill_2
X_5130_ _5130_/A _5670_/B _5130_/C VGND VGND VPWR VPWR _6982_/D sky130_fd_sc_hd__nor3_2
XTAP_TAPCELL_ROW_75_1093 VGND VPWR sky130_fd_sc_hd__tapvpwrvgnd_1
XFILLER_97_634 VGND VGND VPWR VPWR sky130_fd_sc_hd__decap_3
XFILLER_97_612 VGND VGND VPWR VPWR sky130_fd_sc_hd__decap_3
XFILLER_69_358 VGND VGND VPWR VPWR sky130_fd_sc_hd__decap_3
X_5061_ _6988_/D _5060_/X _5061_/S VGND VGND VPWR VPWR _5061_/X sky130_fd_sc_hd__mux2_2
XFILLER_96_188 VGND VGND VPWR VPWR sky130_fd_sc_hd__fill_2
XFILLER_96_155 VGND VGND VPWR VPWR sky130_fd_sc_hd__decap_3
XFILLER_65_520 VGND VGND VPWR VPWR sky130_fd_sc_hd__fill_1
XFILLER_84_339 VGND VGND VPWR VPWR sky130_fd_sc_hd__decap_3
XFILLER_92_350 VGND VGND VPWR VPWR sky130_fd_sc_hd__decap_3
XFILLER_25_439 VGND VGND VPWR VPWR sky130_fd_sc_hd__decap_3
XFILLER_37_299 VGND VGND VPWR VPWR sky130_fd_sc_hd__decap_3
XFILLER_52_225 VGND VGND VPWR VPWR sky130_fd_sc_hd__decap_3
XTAP_TAPCELL_ROW_48_784 VGND VPWR sky130_fd_sc_hd__tapvpwrvgnd_1
XFILLER_18_491 VGND VGND VPWR VPWR sky130_fd_sc_hd__decap_3
XFILLER_80_545 VGND VGND VPWR VPWR sky130_fd_sc_hd__decap_3
X_4914_ _4914_/A0 _4913_/X _4946_/S VGND VGND VPWR VPWR _7267_/D sky130_fd_sc_hd__mux2_2
XFILLER_80_589 VGND VGND VPWR VPWR sky130_fd_sc_hd__decap_3
XFILLER_21_623 VGND VGND VPWR VPWR sky130_fd_sc_hd__decap_3
XFILLER_32_29 VGND VGND VPWR VPWR sky130_fd_sc_hd__decap_3
XFILLER_33_494 VGND VGND VPWR VPWR sky130_fd_sc_hd__decap_3
XFILLER_60_280 VGND VGND VPWR VPWR sky130_fd_sc_hd__decap_3
X_4845_ _4845_/A VGND VGND VPWR VPWR _4872_/A sky130_fd_sc_hd__inv_2
XFILLER_20_144 VGND VGND VPWR VPWR sky130_fd_sc_hd__decap_3
X_4776_ _7004_/Q _4804_/A VGND VGND VPWR VPWR _4777_/C sky130_fd_sc_hd__or2_2
XFILLER_20_177 VGND VGND VPWR VPWR sky130_fd_sc_hd__decap_3
X_6515_ _6618_/A VGND VGND VPWR VPWR _6515_/Y sky130_fd_sc_hd__inv_2
X_3727_ _3746_/B _3733_/C VGND VGND VPWR VPWR _3728_/B sky130_fd_sc_hd__nand2_2
X_6446_ _6541_/A VGND VGND VPWR VPWR _6446_/Y sky130_fd_sc_hd__inv_2
X_6377_ _6612_/A VGND VGND VPWR VPWR _6377_/Y sky130_fd_sc_hd__inv_2
X_3589_ _3589_/A _3589_/B VGND VGND VPWR VPWR _3590_/B sky130_fd_sc_hd__nor2_2
XFILLER_0_516 VGND VGND VPWR VPWR sky130_fd_sc_hd__decap_3
XFILLER_57_15 VGND VGND VPWR VPWR sky130_fd_sc_hd__fill_2
XFILLER_88_645 VGND VGND VPWR VPWR sky130_fd_sc_hd__decap_3
XFILLER_102_466 VGND VGND VPWR VPWR sky130_fd_sc_hd__decap_3
XFILLER_102_477 VGND VGND VPWR VPWR sky130_fd_sc_hd__fill_2
XFILLER_57_37 VGND VGND VPWR VPWR sky130_fd_sc_hd__decap_3
XFILLER_75_328 VGND VGND VPWR VPWR sky130_fd_sc_hd__decap_3
XFILLER_87_155 VGND VGND VPWR VPWR sky130_fd_sc_hd__decap_3
XFILLER_102_499 VGND VGND VPWR VPWR sky130_fd_sc_hd__fill_1
XFILLER_68_380 VGND VGND VPWR VPWR sky130_fd_sc_hd__decap_3
XFILLER_28_233 VGND VGND VPWR VPWR sky130_fd_sc_hd__decap_3
XFILLER_56_542 VGND VGND VPWR VPWR sky130_fd_sc_hd__fill_1
XFILLER_90_309 VGND VGND VPWR VPWR sky130_fd_sc_hd__decap_3
XFILLER_16_417 VGND VGND VPWR VPWR sky130_fd_sc_hd__decap_3
XFILLER_43_203 VGND VGND VPWR VPWR sky130_fd_sc_hd__decap_3
XFILLER_43_225 VGND VGND VPWR VPWR sky130_fd_sc_hd__decap_3
XFILLER_83_361 VGND VGND VPWR VPWR sky130_fd_sc_hd__decap_3
XFILLER_71_556 VGND VGND VPWR VPWR sky130_fd_sc_hd__decap_3
XFILLER_12_601 VGND VGND VPWR VPWR sky130_fd_sc_hd__decap_3
XFILLER_24_450 VGND VGND VPWR VPWR sky130_fd_sc_hd__decap_3
XFILLER_31_409 VGND VGND VPWR VPWR sky130_fd_sc_hd__decap_3
XFILLER_12_634 VGND VGND VPWR VPWR sky130_fd_sc_hd__decap_3
XFILLER_12_645 VGND VGND VPWR VPWR sky130_fd_sc_hd__decap_3
XFILLER_24_483 VGND VGND VPWR VPWR sky130_fd_sc_hd__decap_3
XFILLER_11_144 VGND VGND VPWR VPWR sky130_fd_sc_hd__decap_3
XFILLER_8_616 VGND VGND VPWR VPWR sky130_fd_sc_hd__decap_3
XFILLER_3_343 VGND VGND VPWR VPWR sky130_fd_sc_hd__decap_3
XFILLER_3_387 VGND VGND VPWR VPWR sky130_fd_sc_hd__decap_3
XFILLER_78_111 VGND VGND VPWR VPWR sky130_fd_sc_hd__decap_3
XFILLER_105_293 VGND VGND VPWR VPWR sky130_fd_sc_hd__decap_3
XFILLER_78_144 VGND VGND VPWR VPWR sky130_fd_sc_hd__decap_3
XFILLER_79_645 VGND VGND VPWR VPWR sky130_fd_sc_hd__decap_3
XFILLER_66_306 VGND VGND VPWR VPWR sky130_fd_sc_hd__fill_2
XFILLER_19_200 VGND VGND VPWR VPWR sky130_fd_sc_hd__fill_1
XFILLER_66_339 VGND VGND VPWR VPWR sky130_fd_sc_hd__fill_1
XFILLER_19_233 VGND VGND VPWR VPWR sky130_fd_sc_hd__decap_3
XFILLER_47_553 VGND VGND VPWR VPWR sky130_fd_sc_hd__decap_3
XFILLER_47_564 VGND VGND VPWR VPWR sky130_fd_sc_hd__decap_3
XFILLER_93_158 VGND VGND VPWR VPWR sky130_fd_sc_hd__fill_2
XFILLER_93_169 VGND VGND VPWR VPWR sky130_fd_sc_hd__decap_3
XFILLER_19_277 VGND VGND VPWR VPWR sky130_fd_sc_hd__decap_3
XFILLER_74_361 VGND VGND VPWR VPWR sky130_fd_sc_hd__decap_3
XTAP_TAPCELL_ROW_45_754 VGND VPWR sky130_fd_sc_hd__tapvpwrvgnd_1
XTAP_TAPCELL_ROW_17_434 VGND VPWR sky130_fd_sc_hd__tapvpwrvgnd_1
XFILLER_15_461 VGND VGND VPWR VPWR sky130_fd_sc_hd__decap_3
X_4630_ _4627_/Y _4629_/Y _4372_/A VGND VGND VPWR VPWR _4630_/X sky130_fd_sc_hd__a21o_2
XFILLER_30_486 VGND VGND VPWR VPWR sky130_fd_sc_hd__fill_1
XFILLER_8_64 VGND VGND VPWR VPWR sky130_fd_sc_hd__decap_3
X_6300_ _6622_/A VGND VGND VPWR VPWR _6300_/Y sky130_fd_sc_hd__inv_2
X_4561_ _4561_/A _4573_/B VGND VGND VPWR VPWR _7300_/D sky130_fd_sc_hd__and2_2
XTAP_TAPCELL_ROW_77_1122 VGND VPWR sky130_fd_sc_hd__tapvpwrvgnd_1
X_7280_ _7280_/CLK _7280_/D _6560_/Y VGND VGND VPWR VPWR _7280_/Q sky130_fd_sc_hd__dfrtp_2
Xhold605 _6739_/Q VGND VGND VPWR VPWR _6739_/D sky130_fd_sc_hd__dlygate4sd3_1
Xhold616 _6872_/Q VGND VGND VPWR VPWR _6872_/D sky130_fd_sc_hd__dlygate4sd3_1
Xhold627 _6836_/Q VGND VGND VPWR VPWR _6836_/D sky130_fd_sc_hd__dlygate4sd3_1
XFILLER_6_181 VGND VGND VPWR VPWR sky130_fd_sc_hd__decap_3
Xhold638 _6858_/Q VGND VGND VPWR VPWR _6858_/D sky130_fd_sc_hd__dlygate4sd3_1
Xhold649 _6975_/Q VGND VGND VPWR VPWR _6975_/D sky130_fd_sc_hd__dlygate4sd3_1
XFILLER_103_219 VGND VGND VPWR VPWR sky130_fd_sc_hd__decap_3
XFILLER_69_111 VGND VGND VPWR VPWR sky130_fd_sc_hd__fill_1
X_5113_ _5113_/A _5113_/B VGND VGND VPWR VPWR _5113_/Y sky130_fd_sc_hd__xnor2_2
XFILLER_97_420 VGND VGND VPWR VPWR sky130_fd_sc_hd__decap_3
XFILLER_85_604 VGND VGND VPWR VPWR sky130_fd_sc_hd__decap_3
XFILLER_38_531 VGND VGND VPWR VPWR sky130_fd_sc_hd__fill_1
XFILLER_69_188 VGND VGND VPWR VPWR sky130_fd_sc_hd__decap_3
XFILLER_69_199 VGND VGND VPWR VPWR sky130_fd_sc_hd__decap_3
X_5044_ _5044_/A _5044_/B VGND VGND VPWR VPWR _6988_/D sky130_fd_sc_hd__nor2_2
XFILLER_38_542 VGND VGND VPWR VPWR sky130_fd_sc_hd__fill_2
XFILLER_72_309 VGND VGND VPWR VPWR sky130_fd_sc_hd__decap_3
XFILLER_84_147 VGND VGND VPWR VPWR sky130_fd_sc_hd__fill_1
XFILLER_84_169 VGND VGND VPWR VPWR sky130_fd_sc_hd__decap_3
XTAP_TAPCELL_ROW_88_1251 VGND VPWR sky130_fd_sc_hd__tapvpwrvgnd_1
XFILLER_25_214 VGND VGND VPWR VPWR sky130_fd_sc_hd__decap_3
XFILLER_38_575 VGND VGND VPWR VPWR sky130_fd_sc_hd__decap_3
XFILLER_25_225 VGND VGND VPWR VPWR sky130_fd_sc_hd__decap_3
XFILLER_92_191 VGND VGND VPWR VPWR sky130_fd_sc_hd__decap_3
X_6995_ _7397_/CLK _6995_/D _6275_/Y VGND VGND VPWR VPWR _6995_/Q sky130_fd_sc_hd__dfrtp_2
XPHY_EDGE_ROW_40_Left_149 VGND VGND VPWR VPWR sky130_fd_sc_hd__decap_3
XFILLER_40_206 VGND VGND VPWR VPWR sky130_fd_sc_hd__decap_3
XFILLER_53_589 VGND VGND VPWR VPWR sky130_fd_sc_hd__decap_3
XFILLER_80_375 VGND VGND VPWR VPWR sky130_fd_sc_hd__decap_3
XFILLER_21_464 VGND VGND VPWR VPWR sky130_fd_sc_hd__decap_3
X_4828_ _5006_/A1 _4810_/B _4827_/A _5033_/B2 VGND VGND VPWR VPWR _4828_/X sky130_fd_sc_hd__a22o_2
X_4759_ _4759_/A _4777_/B VGND VGND VPWR VPWR _4760_/B sky130_fd_sc_hd__xnor2_2
XFILLER_107_514 VGND VGND VPWR VPWR sky130_fd_sc_hd__decap_3
XFILLER_108_32 VGND VGND VPWR VPWR sky130_fd_sc_hd__decap_3
X_6429_ _6557_/A VGND VGND VPWR VPWR _6429_/Y sky130_fd_sc_hd__inv_2
XFILLER_0_302 VGND VGND VPWR VPWR sky130_fd_sc_hd__decap_3
XFILLER_0_324 VGND VGND VPWR VPWR sky130_fd_sc_hd__decap_3
XFILLER_0_368 VGND VGND VPWR VPWR sky130_fd_sc_hd__decap_3
XFILLER_0_379 VGND VGND VPWR VPWR sky130_fd_sc_hd__fill_2
XFILLER_76_626 VGND VGND VPWR VPWR sky130_fd_sc_hd__decap_3
XFILLER_102_296 VGND VGND VPWR VPWR sky130_fd_sc_hd__decap_3
XFILLER_75_136 VGND VGND VPWR VPWR sky130_fd_sc_hd__decap_3
XFILLER_29_564 VGND VGND VPWR VPWR sky130_fd_sc_hd__fill_1
XFILLER_75_158 VGND VGND VPWR VPWR sky130_fd_sc_hd__decap_3
XFILLER_75_169 VGND VGND VPWR VPWR sky130_fd_sc_hd__decap_3
XFILLER_44_501 VGND VGND VPWR VPWR sky130_fd_sc_hd__decap_3
Xplace309 _3534_/Y VGND VGND VPWR VPWR _5071_/A sky130_fd_sc_hd__buf_2
XFILLER_16_225 VGND VGND VPWR VPWR sky130_fd_sc_hd__decap_3
XFILLER_44_567 VGND VGND VPWR VPWR sky130_fd_sc_hd__decap_3
XFILLER_71_364 VGND VGND VPWR VPWR sky130_fd_sc_hd__decap_3
XTAP_TAPCELL_ROW_42_713 VGND VPWR sky130_fd_sc_hd__tapvpwrvgnd_1
XFILLER_12_453 VGND VGND VPWR VPWR sky130_fd_sc_hd__decap_3
XFILLER_8_424 VGND VGND VPWR VPWR sky130_fd_sc_hd__fill_1
XTAP_TAPCELL_ROW_22_492 VGND VPWR sky130_fd_sc_hd__tapvpwrvgnd_1
XFILLER_69_9 VGND VGND VPWR VPWR sky130_fd_sc_hd__decap_3
XFILLER_98_206 VGND VGND VPWR VPWR sky130_fd_sc_hd__decap_3
XFILLER_3_184 VGND VGND VPWR VPWR sky130_fd_sc_hd__fill_2
XFILLER_79_431 VGND VGND VPWR VPWR sky130_fd_sc_hd__fill_2
XFILLER_98_239 VGND VGND VPWR VPWR sky130_fd_sc_hd__fill_1
XFILLER_39_306 VGND VGND VPWR VPWR sky130_fd_sc_hd__decap_3
XFILLER_67_615 VGND VGND VPWR VPWR sky130_fd_sc_hd__fill_1
XFILLER_79_464 VGND VGND VPWR VPWR sky130_fd_sc_hd__decap_3
XTAP_TAPCELL_ROW_72_1063 VGND VPWR sky130_fd_sc_hd__tapvpwrvgnd_1
XFILLER_58_80 VGND VGND VPWR VPWR sky130_fd_sc_hd__decap_3
XFILLER_67_637 VGND VGND VPWR VPWR sky130_fd_sc_hd__decap_3
XFILLER_79_497 VGND VGND VPWR VPWR sky130_fd_sc_hd__decap_3
XFILLER_94_434 VGND VGND VPWR VPWR sky130_fd_sc_hd__decap_3
XFILLER_94_445 VGND VGND VPWR VPWR sky130_fd_sc_hd__decap_3
XFILLER_54_309 VGND VGND VPWR VPWR sky130_fd_sc_hd__fill_1
XFILLER_82_607 VGND VGND VPWR VPWR sky130_fd_sc_hd__decap_3
XFILLER_47_383 VGND VGND VPWR VPWR sky130_fd_sc_hd__decap_3
XFILLER_62_320 VGND VGND VPWR VPWR sky130_fd_sc_hd__decap_3
XFILLER_74_180 VGND VGND VPWR VPWR sky130_fd_sc_hd__decap_3
XFILLER_74_191 VGND VGND VPWR VPWR sky130_fd_sc_hd__decap_3
XFILLER_62_353 VGND VGND VPWR VPWR sky130_fd_sc_hd__fill_1
X_6780_ _6976_/CLK _6780_/D VGND VGND VPWR VPWR _6780_/Q sky130_fd_sc_hd__dfxtp_2
X_3992_ _5156_/S _5587_/B VGND VGND VPWR VPWR _3992_/Y sky130_fd_sc_hd__nand2_2
XFILLER_22_217 VGND VGND VPWR VPWR sky130_fd_sc_hd__decap_3
XFILLER_50_559 VGND VGND VPWR VPWR sky130_fd_sc_hd__decap_3
X_5731_ _7371_/Q hold922/X _5737_/S VGND VGND VPWR VPWR _6715_/D sky130_fd_sc_hd__mux2_2
XTAP_TAPCELL_ROW_83_1192 VGND VPWR sky130_fd_sc_hd__tapvpwrvgnd_1
X_5662_ _5662_/A _5662_/B _5662_/C _5661_/X VGND VGND VPWR VPWR _5663_/D sky130_fd_sc_hd__or4b_4
XFILLER_30_283 VGND VGND VPWR VPWR sky130_fd_sc_hd__decap_3
X_7401_ _7406_/CLK _7401_/D _6681_/Y VGND VGND VPWR VPWR _7401_/Q sky130_fd_sc_hd__dfrtp_2
X_5593_ _5593_/A _5595_/B VGND VGND VPWR VPWR _7031_/D sky130_fd_sc_hd__or2_2
X_4613_ _4614_/B _4613_/B _5113_/A VGND VGND VPWR VPWR _4617_/B sky130_fd_sc_hd__and3_2
X_7332_ _7364_/CLK _7332_/D _6612_/Y VGND VGND VPWR VPWR _7332_/Q sky130_fd_sc_hd__dfrtp_2
X_4544_ _7308_/Q _4563_/B VGND VGND VPWR VPWR _7308_/D sky130_fd_sc_hd__and2_2
X_7263_ _7392_/CLK _7263_/D _6543_/Y VGND VGND VPWR VPWR _7263_/Q sky130_fd_sc_hd__dfrtp_2
XFILLER_104_539 VGND VGND VPWR VPWR sky130_fd_sc_hd__decap_3
XFILLER_89_228 VGND VGND VPWR VPWR sky130_fd_sc_hd__decap_3
X_7194_ _7357_/CLK _7194_/D _6474_/Y VGND VGND VPWR VPWR _7194_/Q sky130_fd_sc_hd__dfrtp_2
X_3426_ _3589_/A _3586_/A _3589_/B _3590_/C VGND VGND VPWR VPWR _3427_/B sky130_fd_sc_hd__or4_4
X_3357_ _4537_/B VGND VGND VPWR VPWR _3449_/A sky130_fd_sc_hd__inv_6
XFILLER_57_125 VGND VGND VPWR VPWR sky130_fd_sc_hd__fill_1
XFILLER_58_637 VGND VGND VPWR VPWR sky130_fd_sc_hd__decap_3
XFILLER_85_412 VGND VGND VPWR VPWR sky130_fd_sc_hd__decap_3
Xhold1102 _7317_/Q VGND VGND VPWR VPWR _4524_/A0 sky130_fd_sc_hd__dlygate4sd3_1
Xhold1113 _7290_/Q VGND VGND VPWR VPWR _4581_/A sky130_fd_sc_hd__dlygate4sd3_1
Xhold1124 _7285_/Q VGND VGND VPWR VPWR _4591_/A sky130_fd_sc_hd__dlygate4sd3_1
XFILLER_45_309 VGND VGND VPWR VPWR sky130_fd_sc_hd__decap_3
XFILLER_57_169 VGND VGND VPWR VPWR sky130_fd_sc_hd__decap_3
XFILLER_73_607 VGND VGND VPWR VPWR sky130_fd_sc_hd__decap_3
Xhold1135 _7291_/Q VGND VGND VPWR VPWR _4579_/A sky130_fd_sc_hd__dlygate4sd3_1
Xhold1146 _7296_/Q VGND VGND VPWR VPWR _4569_/A sky130_fd_sc_hd__dlygate4sd3_1
Xhold1157 _7161_/Q VGND VGND VPWR VPWR _5340_/A0 sky130_fd_sc_hd__dlygate4sd3_1
X_5027_ _5092_/C _5024_/X _6990_/D _5666_/A VGND VGND VPWR VPWR _5027_/X sky130_fd_sc_hd__a22o_2
XFILLER_38_372 VGND VGND VPWR VPWR sky130_fd_sc_hd__decap_3
XFILLER_85_489 VGND VGND VPWR VPWR sky130_fd_sc_hd__decap_3
Xhold1168 _7121_/Q VGND VGND VPWR VPWR _5425_/A0 sky130_fd_sc_hd__dlygate4sd3_1
Xhold1179 _7154_/Q VGND VGND VPWR VPWR _5354_/A0 sky130_fd_sc_hd__dlygate4sd3_1
XFILLER_38_394 VGND VGND VPWR VPWR sky130_fd_sc_hd__fill_2
XFILLER_72_139 VGND VGND VPWR VPWR sky130_fd_sc_hd__fill_1
XFILLER_26_589 VGND VGND VPWR VPWR sky130_fd_sc_hd__fill_1
XFILLER_53_353 VGND VGND VPWR VPWR sky130_fd_sc_hd__fill_2
XFILLER_53_375 VGND VGND VPWR VPWR sky130_fd_sc_hd__decap_3
XFILLER_13_228 VGND VGND VPWR VPWR sky130_fd_sc_hd__decap_3
XFILLER_41_548 VGND VGND VPWR VPWR sky130_fd_sc_hd__decap_3
XFILLER_80_172 VGND VGND VPWR VPWR sky130_fd_sc_hd__decap_3
X_6978_ clkload3/A _6978_/D VGND VGND VPWR VPWR _6978_/Q sky130_fd_sc_hd__dfxtp_2
XFILLER_41_559 VGND VGND VPWR VPWR sky130_fd_sc_hd__fill_1
XFILLER_70_48 VGND VGND VPWR VPWR sky130_fd_sc_hd__fill_2
XFILLER_5_449 VGND VGND VPWR VPWR sky130_fd_sc_hd__fill_1
XFILLER_102_3 VGND VGND VPWR VPWR sky130_fd_sc_hd__decap_3
XFILLER_107_377 VGND VGND VPWR VPWR sky130_fd_sc_hd__decap_3
XFILLER_1_611 VGND VGND VPWR VPWR sky130_fd_sc_hd__decap_3
XFILLER_107_399 VGND VGND VPWR VPWR sky130_fd_sc_hd__decap_3
Xhold991 _7187_/Q VGND VGND VPWR VPWR hold991/X sky130_fd_sc_hd__dlygate4sd3_1
Xhold980 _7047_/Q VGND VGND VPWR VPWR hold980/X sky130_fd_sc_hd__dlygate4sd3_1
XFILLER_49_615 VGND VGND VPWR VPWR sky130_fd_sc_hd__fill_1
XFILLER_76_401 VGND VGND VPWR VPWR sky130_fd_sc_hd__decap_3
XFILLER_103_594 VGND VGND VPWR VPWR sky130_fd_sc_hd__fill_1
XFILLER_49_626 VGND VGND VPWR VPWR sky130_fd_sc_hd__decap_3
XFILLER_36_309 VGND VGND VPWR VPWR sky130_fd_sc_hd__fill_1
XFILLER_48_147 VGND VGND VPWR VPWR sky130_fd_sc_hd__decap_3
XFILLER_76_456 VGND VGND VPWR VPWR sky130_fd_sc_hd__decap_3
XFILLER_29_372 VGND VGND VPWR VPWR sky130_fd_sc_hd__decap_3
XFILLER_64_629 VGND VGND VPWR VPWR sky130_fd_sc_hd__decap_3
XFILLER_76_489 VGND VGND VPWR VPWR sky130_fd_sc_hd__decap_3
XFILLER_17_523 VGND VGND VPWR VPWR sky130_fd_sc_hd__decap_3
XFILLER_28_94 VGND VGND VPWR VPWR sky130_fd_sc_hd__fill_1
XFILLER_32_515 VGND VGND VPWR VPWR sky130_fd_sc_hd__decap_3
XFILLER_44_375 VGND VGND VPWR VPWR sky130_fd_sc_hd__decap_3
XTAP_TAPCELL_ROW_55_871 VGND VPWR sky130_fd_sc_hd__tapvpwrvgnd_1
XTAP_TAPCELL_ROW_27_540 VGND VPWR sky130_fd_sc_hd__tapvpwrvgnd_1
XTAP_TAPCELL_ROW_106_1457 VGND VPWR sky130_fd_sc_hd__tapvpwrvgnd_1
XFILLER_71_161 VGND VGND VPWR VPWR sky130_fd_sc_hd__decap_3
XFILLER_71_172 VGND VGND VPWR VPWR sky130_fd_sc_hd__decap_3
XFILLER_71_194 VGND VGND VPWR VPWR sky130_fd_sc_hd__decap_3
XFILLER_12_272 VGND VGND VPWR VPWR sky130_fd_sc_hd__decap_3
XFILLER_8_221 VGND VGND VPWR VPWR sky130_fd_sc_hd__decap_3
XFILLER_8_265 VGND VGND VPWR VPWR sky130_fd_sc_hd__decap_3
XFILLER_8_287 VGND VGND VPWR VPWR sky130_fd_sc_hd__decap_3
Xoutput518 _6987_/Q VGND VGND VPWR VPWR pc_out[10] sky130_fd_sc_hd__clkdlybuf4s25_1
Xoutput507 place390/X VGND VGND VPWR VPWR instruction_out[28] sky130_fd_sc_hd__clkdlybuf4s25_1
Xoutput529 _6997_/Q VGND VGND VPWR VPWR pc_out[20] sky130_fd_sc_hd__clkdlybuf4s25_1
X_4260_ _7262_/Q _4260_/A2 _4414_/B1 _7326_/Q VGND VGND VPWR VPWR _4264_/A sky130_fd_sc_hd__a22o_2
XFILLER_99_548 VGND VGND VPWR VPWR sky130_fd_sc_hd__decap_3
XFILLER_79_250 VGND VGND VPWR VPWR sky130_fd_sc_hd__decap_3
X_4191_ _7071_/Q _4265_/B _4205_/A VGND VGND VPWR VPWR _4637_/C sky130_fd_sc_hd__o21a_2
XPHY_EDGE_ROW_105_Left_214 VGND VGND VPWR VPWR sky130_fd_sc_hd__decap_3
XFILLER_39_125 VGND VGND VPWR VPWR sky130_fd_sc_hd__decap_3
XFILLER_67_434 VGND VGND VPWR VPWR sky130_fd_sc_hd__decap_3
XFILLER_79_272 VGND VGND VPWR VPWR sky130_fd_sc_hd__decap_3
XFILLER_39_158 VGND VGND VPWR VPWR sky130_fd_sc_hd__decap_3
XFILLER_55_607 VGND VGND VPWR VPWR sky130_fd_sc_hd__decap_3
XFILLER_94_253 VGND VGND VPWR VPWR sky130_fd_sc_hd__decap_3
XFILLER_39_169 VGND VGND VPWR VPWR sky130_fd_sc_hd__decap_3
XFILLER_55_629 VGND VGND VPWR VPWR sky130_fd_sc_hd__decap_3
XFILLER_35_331 VGND VGND VPWR VPWR sky130_fd_sc_hd__decap_3
X_6901_ clkload7/A _6901_/D VGND VGND VPWR VPWR _6901_/Q sky130_fd_sc_hd__dfxtp_2
XTAP_TAPCELL_ROW_85_1210 VGND VPWR sky130_fd_sc_hd__tapvpwrvgnd_1
X_6832_ _6958_/CLK _6832_/D VGND VGND VPWR VPWR _6832_/Q sky130_fd_sc_hd__dfxtp_2
XFILLER_23_537 VGND VGND VPWR VPWR sky130_fd_sc_hd__decap_3
X_6763_ _6966_/CLK _6763_/D VGND VGND VPWR VPWR _6763_/Q sky130_fd_sc_hd__dfxtp_2
X_3975_ _7353_/Q _4517_/A0 _3975_/S VGND VGND VPWR VPWR _7353_/D sky130_fd_sc_hd__mux2_2
XFILLER_10_209 VGND VGND VPWR VPWR sky130_fd_sc_hd__decap_3
X_6694_ _7350_/CLK _6694_/D VGND VGND VPWR VPWR _6694_/Q sky130_fd_sc_hd__dfxtp_2
XFILLER_31_592 VGND VGND VPWR VPWR sky130_fd_sc_hd__decap_3
X_5645_ _5129_/A _5129_/B _3519_/B _5644_/X VGND VGND VPWR VPWR _5645_/X sky130_fd_sc_hd__o31a_2
X_5576_ hold942/X _5587_/B _5015_/X VGND VGND VPWR VPWR _7041_/D sky130_fd_sc_hd__a21o_2
XFILLER_2_419 VGND VGND VPWR VPWR sky130_fd_sc_hd__fill_1
X_7315_ _7350_/CLK _7315_/D _6595_/Y VGND VGND VPWR VPWR _7315_/Q sky130_fd_sc_hd__dfrtp_2
X_7246_ _7372_/CLK _7246_/D _6526_/Y VGND VGND VPWR VPWR _7246_/Q sky130_fd_sc_hd__dfrtp_2
X_4458_ _4458_/A _4039_/A VGND VGND VPWR VPWR _4458_/X sky130_fd_sc_hd__or2b_2
X_7177_ _7406_/CLK _7177_/D _6457_/Y VGND VGND VPWR VPWR _7177_/Q sky130_fd_sc_hd__dfrtp_2
X_3409_ _3449_/A _3449_/B _3421_/C _3409_/D VGND VGND VPWR VPWR _3409_/X sky130_fd_sc_hd__and4_2
XFILLER_105_11 VGND VGND VPWR VPWR sky130_fd_sc_hd__decap_3
X_4389_ _7081_/Q _4102_/B _4432_/B1 _4388_/X VGND VGND VPWR VPWR _4396_/A sky130_fd_sc_hd__o211ai_2
XFILLER_98_592 VGND VGND VPWR VPWR sky130_fd_sc_hd__decap_3
XFILLER_100_542 VGND VGND VPWR VPWR sky130_fd_sc_hd__decap_3
XFILLER_105_44 VGND VGND VPWR VPWR sky130_fd_sc_hd__decap_3
XFILLER_105_66 VGND VGND VPWR VPWR sky130_fd_sc_hd__decap_3
XFILLER_85_231 VGND VGND VPWR VPWR sky130_fd_sc_hd__decap_3
XFILLER_85_253 VGND VGND VPWR VPWR sky130_fd_sc_hd__decap_3
XFILLER_100_586 VGND VGND VPWR VPWR sky130_fd_sc_hd__fill_2
XFILLER_46_629 VGND VGND VPWR VPWR sky130_fd_sc_hd__decap_3
XFILLER_73_426 VGND VGND VPWR VPWR sky130_fd_sc_hd__decap_3
XFILLER_38_191 VGND VGND VPWR VPWR sky130_fd_sc_hd__fill_1
XFILLER_45_128 VGND VGND VPWR VPWR sky130_fd_sc_hd__decap_3
XFILLER_53_150 VGND VGND VPWR VPWR sky130_fd_sc_hd__decap_3
XFILLER_41_323 VGND VGND VPWR VPWR sky130_fd_sc_hd__decap_3
XFILLER_53_172 VGND VGND VPWR VPWR sky130_fd_sc_hd__decap_3
XFILLER_81_470 VGND VGND VPWR VPWR sky130_fd_sc_hd__decap_3
XTAP_TAPCELL_ROW_24_510 VGND VPWR sky130_fd_sc_hd__tapvpwrvgnd_1
XTAP_TAPCELL_ROW_52_830 VGND VPWR sky130_fd_sc_hd__tapvpwrvgnd_1
XFILLER_14_41 VGND VGND VPWR VPWR sky130_fd_sc_hd__fill_2
XFILLER_41_378 VGND VGND VPWR VPWR sky130_fd_sc_hd__decap_3
XFILLER_14_74 VGND VGND VPWR VPWR sky130_fd_sc_hd__decap_3
XFILLER_14_85 VGND VGND VPWR VPWR sky130_fd_sc_hd__decap_3
XFILLER_22_592 VGND VGND VPWR VPWR sky130_fd_sc_hd__decap_3
XTAP_TAPCELL_ROW_101_1398 VGND VPWR sky130_fd_sc_hd__tapvpwrvgnd_1
XFILLER_108_620 VGND VGND VPWR VPWR sky130_fd_sc_hd__fill_1
XFILLER_5_257 VGND VGND VPWR VPWR sky130_fd_sc_hd__decap_3
XFILLER_68_209 VGND VGND VPWR VPWR sky130_fd_sc_hd__decap_3
XFILLER_96_507 VGND VGND VPWR VPWR sky130_fd_sc_hd__fill_1
XFILLER_37_607 VGND VGND VPWR VPWR sky130_fd_sc_hd__decap_3
XFILLER_39_93 VGND VGND VPWR VPWR sky130_fd_sc_hd__decap_3
XFILLER_49_434 VGND VGND VPWR VPWR sky130_fd_sc_hd__decap_3
XFILLER_49_445 VGND VGND VPWR VPWR sky130_fd_sc_hd__decap_3
XFILLER_37_629 VGND VGND VPWR VPWR sky130_fd_sc_hd__decap_3
XFILLER_49_489 VGND VGND VPWR VPWR sky130_fd_sc_hd__decap_3
XFILLER_64_426 VGND VGND VPWR VPWR sky130_fd_sc_hd__decap_3
XFILLER_76_253 VGND VGND VPWR VPWR sky130_fd_sc_hd__decap_3
XFILLER_36_139 VGND VGND VPWR VPWR sky130_fd_sc_hd__fill_1
XFILLER_91_212 VGND VGND VPWR VPWR sky130_fd_sc_hd__decap_3
XFILLER_91_234 VGND VGND VPWR VPWR sky130_fd_sc_hd__decap_3
XFILLER_17_364 VGND VGND VPWR VPWR sky130_fd_sc_hd__decap_3
XFILLER_44_150 VGND VGND VPWR VPWR sky130_fd_sc_hd__decap_3
XFILLER_91_267 VGND VGND VPWR VPWR sky130_fd_sc_hd__decap_3
XFILLER_32_301 VGND VGND VPWR VPWR sky130_fd_sc_hd__decap_3
XFILLER_32_323 VGND VGND VPWR VPWR sky130_fd_sc_hd__decap_3
XFILLER_60_621 VGND VGND VPWR VPWR sky130_fd_sc_hd__decap_3
XFILLER_72_470 VGND VGND VPWR VPWR sky130_fd_sc_hd__decap_3
XFILLER_13_570 VGND VGND VPWR VPWR sky130_fd_sc_hd__decap_3
X_3760_ _6933_/Q _3862_/A2 _3823_/A2 _6707_/Q VGND VGND VPWR VPWR _3760_/X sky130_fd_sc_hd__a22o_2
XTAP_TAPCELL_ROW_80_1151 VGND VPWR sky130_fd_sc_hd__tapvpwrvgnd_1
XFILLER_9_552 VGND VGND VPWR VPWR sky130_fd_sc_hd__fill_1
X_3691_ _6941_/Q _3884_/A2 _3824_/B1 _6805_/Q VGND VGND VPWR VPWR _3691_/X sky130_fd_sc_hd__a22o_2
XTAP_TAPCELL_ROW_30_579 VGND VPWR sky130_fd_sc_hd__tapvpwrvgnd_1
XFILLER_9_585 VGND VGND VPWR VPWR sky130_fd_sc_hd__decap_3
XFILLER_99_301 VGND VGND VPWR VPWR sky130_fd_sc_hd__fill_1
X_7100_ _7352_/CLK _7100_/D _6380_/Y VGND VGND VPWR VPWR _7100_/Q sky130_fd_sc_hd__dfrtp_2
X_5292_ hold992/X _4470_/X _5292_/S VGND VGND VPWR VPWR _7183_/D sky130_fd_sc_hd__mux2_2
X_4312_ _4394_/A _4337_/B _4311_/X VGND VGND VPWR VPWR _4313_/D sky130_fd_sc_hd__or3b_2
XFILLER_99_334 VGND VGND VPWR VPWR sky130_fd_sc_hd__fill_2
X_7031_ _7355_/CLK _7031_/D _6311_/Y VGND VGND VPWR VPWR _7031_/Q sky130_fd_sc_hd__dfrtp_2
X_4243_ _4620_/A _5032_/A VGND VGND VPWR VPWR _4243_/Y sky130_fd_sc_hd__nor2_2
XFILLER_101_328 VGND VGND VPWR VPWR sky130_fd_sc_hd__decap_3
XFILLER_87_529 VGND VGND VPWR VPWR sky130_fd_sc_hd__fill_2
XTAP_TAPCELL_ROW_91_1280 VGND VPWR sky130_fd_sc_hd__tapvpwrvgnd_1
XFILLER_99_389 VGND VGND VPWR VPWR sky130_fd_sc_hd__decap_3
XFILLER_28_607 VGND VGND VPWR VPWR sky130_fd_sc_hd__decap_3
X_4174_ _7296_/Q _4495_/S _4354_/B1 _7360_/Q VGND VGND VPWR VPWR _4174_/X sky130_fd_sc_hd__a22o_2
XFILLER_95_551 VGND VGND VPWR VPWR sky130_fd_sc_hd__decap_3
XFILLER_55_415 VGND VGND VPWR VPWR sky130_fd_sc_hd__decap_3
XFILLER_70_407 VGND VGND VPWR VPWR sky130_fd_sc_hd__decap_3
XFILLER_82_245 VGND VGND VPWR VPWR sky130_fd_sc_hd__decap_3
XFILLER_82_256 VGND VGND VPWR VPWR sky130_fd_sc_hd__decap_3
XTAP_TAPCELL_ROW_66_988 VGND VPWR sky130_fd_sc_hd__tapvpwrvgnd_1
XTAP_TAPCELL_ROW_38_668 VGND VPWR sky130_fd_sc_hd__tapvpwrvgnd_1
XFILLER_51_632 VGND VGND VPWR VPWR sky130_fd_sc_hd__decap_3
XFILLER_63_481 VGND VGND VPWR VPWR sky130_fd_sc_hd__fill_1
XFILLER_82_289 VGND VGND VPWR VPWR sky130_fd_sc_hd__decap_3
XTAP_TAPCELL_ROW_66_999 VGND VPWR sky130_fd_sc_hd__tapvpwrvgnd_1
XFILLER_23_345 VGND VGND VPWR VPWR sky130_fd_sc_hd__decap_3
X_6815_ _6958_/CLK _6815_/D VGND VGND VPWR VPWR _6815_/Q sky130_fd_sc_hd__dfxtp_2
XFILLER_23_389 VGND VGND VPWR VPWR sky130_fd_sc_hd__decap_3
XFILLER_50_153 VGND VGND VPWR VPWR sky130_fd_sc_hd__decap_3
X_6746_ clkload8/A _6746_/D VGND VGND VPWR VPWR _6746_/Q sky130_fd_sc_hd__dfxtp_2
XFILLER_50_197 VGND VGND VPWR VPWR sky130_fd_sc_hd__decap_3
X_3958_ _7361_/Q _4501_/A0 _3958_/S VGND VGND VPWR VPWR _7361_/D sky130_fd_sc_hd__mux2_2
X_6677_ _6677_/A VGND VGND VPWR VPWR _6677_/Y sky130_fd_sc_hd__inv_2
X_3889_ _6834_/Q _3889_/A2 _3911_/A2 _6829_/Q _3888_/X VGND VGND VPWR VPWR _3889_/X
+ sky130_fd_sc_hd__a221o_2
X_5628_ _5628_/A _5628_/B VGND VGND VPWR VPWR _7014_/D sky130_fd_sc_hd__or2_2
XFILLER_2_205 VGND VGND VPWR VPWR sky130_fd_sc_hd__fill_2
XFILLER_105_623 VGND VGND VPWR VPWR sky130_fd_sc_hd__decap_3
XFILLER_104_144 VGND VGND VPWR VPWR sky130_fd_sc_hd__decap_3
XFILLER_104_177 VGND VGND VPWR VPWR sky130_fd_sc_hd__decap_3
X_7229_ _7362_/CLK _7229_/D _6509_/Y VGND VGND VPWR VPWR _7229_/Q sky130_fd_sc_hd__dfrtp_2
XFILLER_100_361 VGND VGND VPWR VPWR sky130_fd_sc_hd__decap_3
XFILLER_19_629 VGND VGND VPWR VPWR sky130_fd_sc_hd__decap_3
XFILLER_46_404 VGND VGND VPWR VPWR sky130_fd_sc_hd__decap_3
XFILLER_58_253 VGND VGND VPWR VPWR sky130_fd_sc_hd__decap_3
XFILLER_73_201 VGND VGND VPWR VPWR sky130_fd_sc_hd__decap_3
XFILLER_100_394 VGND VGND VPWR VPWR sky130_fd_sc_hd__fill_2
XFILLER_18_117 VGND VGND VPWR VPWR sky130_fd_sc_hd__decap_3
XFILLER_46_459 VGND VGND VPWR VPWR sky130_fd_sc_hd__decap_3
XFILLER_58_286 VGND VGND VPWR VPWR sky130_fd_sc_hd__decap_3
XFILLER_73_234 VGND VGND VPWR VPWR sky130_fd_sc_hd__decap_3
XFILLER_33_109 VGND VGND VPWR VPWR sky130_fd_sc_hd__decap_3
XFILLER_61_418 VGND VGND VPWR VPWR sky130_fd_sc_hd__decap_3
XFILLER_92_24 VGND VGND VPWR VPWR sky130_fd_sc_hd__decap_3
XFILLER_92_35 VGND VGND VPWR VPWR sky130_fd_sc_hd__fill_1
XFILLER_14_301 VGND VGND VPWR VPWR sky130_fd_sc_hd__decap_3
XFILLER_26_161 VGND VGND VPWR VPWR sky130_fd_sc_hd__fill_1
XFILLER_42_621 VGND VGND VPWR VPWR sky130_fd_sc_hd__decap_3
XFILLER_54_470 VGND VGND VPWR VPWR sky130_fd_sc_hd__fill_2
XTAP_TAPCELL_ROW_103_1416 VGND VPWR sky130_fd_sc_hd__tapvpwrvgnd_1
XFILLER_14_345 VGND VGND VPWR VPWR sky130_fd_sc_hd__decap_3
XFILLER_25_40 VGND VGND VPWR VPWR sky130_fd_sc_hd__decap_3
XFILLER_26_183 VGND VGND VPWR VPWR sky130_fd_sc_hd__decap_3
XFILLER_14_378 VGND VGND VPWR VPWR sky130_fd_sc_hd__fill_1
XFILLER_25_84 VGND VGND VPWR VPWR sky130_fd_sc_hd__fill_2
XFILLER_41_164 VGND VGND VPWR VPWR sky130_fd_sc_hd__decap_3
XFILLER_41_175 VGND VGND VPWR VPWR sky130_fd_sc_hd__decap_3
XFILLER_10_540 VGND VGND VPWR VPWR sky130_fd_sc_hd__decap_3
XFILLER_10_595 VGND VGND VPWR VPWR sky130_fd_sc_hd__decap_3
XFILLER_6_566 VGND VGND VPWR VPWR sky130_fd_sc_hd__decap_3
XFILLER_108_494 VGND VGND VPWR VPWR sky130_fd_sc_hd__fill_1
XFILLER_96_359 VGND VGND VPWR VPWR sky130_fd_sc_hd__decap_3
XFILLER_49_264 VGND VGND VPWR VPWR sky130_fd_sc_hd__fill_1
XFILLER_77_573 VGND VGND VPWR VPWR sky130_fd_sc_hd__fill_2
XFILLER_2_88 VGND VGND VPWR VPWR sky130_fd_sc_hd__fill_1
XFILLER_64_223 VGND VGND VPWR VPWR sky130_fd_sc_hd__decap_3
XTAP_TAPCELL_ROW_69_1024 VGND VPWR sky130_fd_sc_hd__tapvpwrvgnd_1
XFILLER_18_640 VGND VGND VPWR VPWR sky130_fd_sc_hd__decap_3
XFILLER_64_267 VGND VGND VPWR VPWR sky130_fd_sc_hd__fill_1
XFILLER_33_610 VGND VGND VPWR VPWR sky130_fd_sc_hd__decap_3
XFILLER_52_418 VGND VGND VPWR VPWR sky130_fd_sc_hd__fill_2
XFILLER_92_598 VGND VGND VPWR VPWR sky130_fd_sc_hd__fill_1
X_4930_ _6995_/Q _4963_/A _6996_/Q VGND VGND VPWR VPWR _4931_/B sky130_fd_sc_hd__a21oi_2
XTAP_TAPCELL_ROW_35_638 VGND VPWR sky130_fd_sc_hd__tapvpwrvgnd_1
XFILLER_17_183 VGND VGND VPWR VPWR sky130_fd_sc_hd__decap_3
XFILLER_33_632 VGND VGND VPWR VPWR sky130_fd_sc_hd__decap_3
XFILLER_60_440 VGND VGND VPWR VPWR sky130_fd_sc_hd__decap_3
X_4861_ _6998_/Q _6999_/Q _4912_/A _7000_/Q VGND VGND VPWR VPWR _4862_/B sky130_fd_sc_hd__a31o_2
XTAP_TAPCELL_ROW_63_958 VGND VPWR sky130_fd_sc_hd__tapvpwrvgnd_1
XFILLER_20_304 VGND VGND VPWR VPWR sky130_fd_sc_hd__decap_3
XFILLER_32_164 VGND VGND VPWR VPWR sky130_fd_sc_hd__fill_1
XFILLER_60_473 VGND VGND VPWR VPWR sky130_fd_sc_hd__decap_3
X_6600_ _6624_/A VGND VGND VPWR VPWR _6600_/Y sky130_fd_sc_hd__inv_2
X_3812_ _3725_/X _3804_/X _3806_/X _3728_/Y _3811_/X VGND VGND VPWR VPWR _3812_/X
+ sky130_fd_sc_hd__a221o_2
XFILLER_20_326 VGND VGND VPWR VPWR sky130_fd_sc_hd__fill_1
XFILLER_32_197 VGND VGND VPWR VPWR sky130_fd_sc_hd__decap_3
X_4792_ _4878_/A1 _7004_/D _4777_/X _4791_/Y VGND VGND VPWR VPWR _4792_/X sky130_fd_sc_hd__a211o_2
X_6531_ _6625_/A VGND VGND VPWR VPWR _6531_/Y sky130_fd_sc_hd__inv_2
X_3743_ _6848_/Q _3886_/A2 _3853_/A2 _6838_/Q _3742_/X VGND VGND VPWR VPWR _3743_/X
+ sky130_fd_sc_hd__a221o_2
X_6462_ _6589_/A VGND VGND VPWR VPWR _6462_/Y sky130_fd_sc_hd__inv_2
X_3674_ _6806_/Q VGND VGND VPWR VPWR _3674_/Y sky130_fd_sc_hd__inv_2
XFILLER_9_393 VGND VGND VPWR VPWR sky130_fd_sc_hd__decap_3
X_6393_ _6556_/A VGND VGND VPWR VPWR _6393_/Y sky130_fd_sc_hd__inv_2
X_5413_ _5413_/A0 _5107_/X _5427_/S VGND VGND VPWR VPWR _7127_/D sky130_fd_sc_hd__mux2_2
X_5344_ _5344_/A0 _5107_/X _5358_/S VGND VGND VPWR VPWR _7159_/D sky130_fd_sc_hd__mux2_2
XTAP_TAPCELL_ROW_7_319 VGND VPWR sky130_fd_sc_hd__tapvpwrvgnd_1
XFILLER_99_131 VGND VGND VPWR VPWR sky130_fd_sc_hd__decap_3
XFILLER_102_615 VGND VGND VPWR VPWR sky130_fd_sc_hd__decap_3
XFILLER_87_326 VGND VGND VPWR VPWR sky130_fd_sc_hd__fill_2
XFILLER_99_175 VGND VGND VPWR VPWR sky130_fd_sc_hd__decap_3
XFILLER_99_164 VGND VGND VPWR VPWR sky130_fd_sc_hd__decap_3
XFILLER_101_125 VGND VGND VPWR VPWR sky130_fd_sc_hd__decap_3
XFILLER_87_337 VGND VGND VPWR VPWR sky130_fd_sc_hd__decap_3
XFILLER_87_359 VGND VGND VPWR VPWR sky130_fd_sc_hd__decap_3
X_7014_ _7357_/CLK _7014_/D _6294_/Y VGND VGND VPWR VPWR _7014_/Q sky130_fd_sc_hd__dfrtp_2
X_4226_ _4372_/A _4627_/A VGND VGND VPWR VPWR _4620_/A sky130_fd_sc_hd__nor2_2
XFILLER_101_169 VGND VGND VPWR VPWR sky130_fd_sc_hd__decap_3
X_4157_ _4157_/A _4205_/C VGND VGND VPWR VPWR _4158_/B sky130_fd_sc_hd__nand2_2
XFILLER_55_223 VGND VGND VPWR VPWR sky130_fd_sc_hd__fill_1
XFILLER_55_234 VGND VGND VPWR VPWR sky130_fd_sc_hd__fill_2
XFILLER_68_595 VGND VGND VPWR VPWR sky130_fd_sc_hd__decap_3
XFILLER_95_370 VGND VGND VPWR VPWR sky130_fd_sc_hd__decap_3
XFILLER_102_12 VGND VGND VPWR VPWR sky130_fd_sc_hd__decap_3
X_4088_ _7238_/Q _4414_/A2 _4501_/S _7051_/Q VGND VGND VPWR VPWR _4088_/X sky130_fd_sc_hd__a22o_2
XFILLER_15_109 VGND VGND VPWR VPWR sky130_fd_sc_hd__decap_3
XFILLER_24_610 VGND VGND VPWR VPWR sky130_fd_sc_hd__decap_3
XFILLER_24_643 VGND VGND VPWR VPWR sky130_fd_sc_hd__fill_1
XFILLER_51_440 VGND VGND VPWR VPWR sky130_fd_sc_hd__decap_3
XFILLER_70_259 VGND VGND VPWR VPWR sky130_fd_sc_hd__fill_2
XFILLER_23_153 VGND VGND VPWR VPWR sky130_fd_sc_hd__decap_3
XFILLER_11_326 VGND VGND VPWR VPWR sky130_fd_sc_hd__decap_3
XFILLER_11_337 VGND VGND VPWR VPWR sky130_fd_sc_hd__decap_3
XFILLER_23_175 VGND VGND VPWR VPWR sky130_fd_sc_hd__decap_3
XFILLER_7_319 VGND VGND VPWR VPWR sky130_fd_sc_hd__decap_3
X_6729_ clkload8/A _6729_/D VGND VGND VPWR VPWR _6729_/Q sky130_fd_sc_hd__dfxtp_2
XFILLER_3_503 VGND VGND VPWR VPWR sky130_fd_sc_hd__fill_1
XFILLER_105_420 VGND VGND VPWR VPWR sky130_fd_sc_hd__decap_3
XFILLER_3_547 VGND VGND VPWR VPWR sky130_fd_sc_hd__decap_3
XFILLER_105_464 VGND VGND VPWR VPWR sky130_fd_sc_hd__decap_3
XFILLER_78_304 VGND VGND VPWR VPWR sky130_fd_sc_hd__decap_3
XFILLER_87_57 VGND VGND VPWR VPWR sky130_fd_sc_hd__decap_3
XFILLER_19_426 VGND VGND VPWR VPWR sky130_fd_sc_hd__decap_3
XFILLER_100_191 VGND VGND VPWR VPWR sky130_fd_sc_hd__decap_3
XFILLER_46_256 VGND VGND VPWR VPWR sky130_fd_sc_hd__decap_3
XFILLER_15_632 VGND VGND VPWR VPWR sky130_fd_sc_hd__decap_3
XFILLER_61_259 VGND VGND VPWR VPWR sky130_fd_sc_hd__decap_3
XFILLER_14_164 VGND VGND VPWR VPWR sky130_fd_sc_hd__decap_3
XFILLER_30_613 VGND VGND VPWR VPWR sky130_fd_sc_hd__decap_3
XTAP_TAPCELL_ROW_60_928 VGND VPWR sky130_fd_sc_hd__tapvpwrvgnd_1
XTAP_TAPCELL_ROW_32_608 VGND VPWR sky130_fd_sc_hd__tapvpwrvgnd_1
XFILLER_99_9 VGND VGND VPWR VPWR sky130_fd_sc_hd__decap_3
XFILLER_14_197 VGND VGND VPWR VPWR sky130_fd_sc_hd__decap_3
XTAP_TAPCELL_ROW_40_696 VGND VPWR sky130_fd_sc_hd__tapvpwrvgnd_1
XTAP_TAPCELL_ROW_12_376 VGND VPWR sky130_fd_sc_hd__tapvpwrvgnd_1
XFILLER_6_330 VGND VGND VPWR VPWR sky130_fd_sc_hd__decap_3
XFILLER_6_352 VGND VGND VPWR VPWR sky130_fd_sc_hd__decap_3
Xhold809 _6931_/Q VGND VGND VPWR VPWR _6931_/D sky130_fd_sc_hd__dlygate4sd3_1
XFILLER_6_374 VGND VGND VPWR VPWR sky130_fd_sc_hd__decap_3
XFILLER_6_385 VGND VGND VPWR VPWR sky130_fd_sc_hd__decap_3
X_3390_ _7155_/Q _3366_/X _3379_/X _3389_/X VGND VGND VPWR VPWR _3390_/X sky130_fd_sc_hd__a211o_2
XTAP_TAPCELL_ROW_75_1094 VGND VPWR sky130_fd_sc_hd__tapvpwrvgnd_1
X_5060_ _4467_/Y _5045_/X _5059_/X _4467_/B VGND VGND VPWR VPWR _5060_/X sky130_fd_sc_hd__a22o_2
XFILLER_97_646 VGND VGND VPWR VPWR sky130_fd_sc_hd__fill_2
XFILLER_96_123 VGND VGND VPWR VPWR sky130_fd_sc_hd__decap_3
XFILLER_84_307 VGND VGND VPWR VPWR sky130_fd_sc_hd__fill_1
XFILLER_84_318 VGND VGND VPWR VPWR sky130_fd_sc_hd__decap_3
X_4011_ _7342_/Q _3943_/S _4419_/B1 _7374_/Q _4429_/C1 VGND VGND VPWR VPWR _4011_/X
+ sky130_fd_sc_hd__a221o_2
XFILLER_96_167 VGND VGND VPWR VPWR sky130_fd_sc_hd__fill_2
XFILLER_65_532 VGND VGND VPWR VPWR sky130_fd_sc_hd__fill_2
XFILLER_37_234 VGND VGND VPWR VPWR sky130_fd_sc_hd__decap_3
XFILLER_37_256 VGND VGND VPWR VPWR sky130_fd_sc_hd__decap_3
XFILLER_18_470 VGND VGND VPWR VPWR sky130_fd_sc_hd__decap_3
XFILLER_52_204 VGND VGND VPWR VPWR sky130_fd_sc_hd__decap_3
XFILLER_92_362 VGND VGND VPWR VPWR sky130_fd_sc_hd__fill_2
XFILLER_92_384 VGND VGND VPWR VPWR sky130_fd_sc_hd__decap_3
XTAP_TAPCELL_ROW_48_785 VGND VPWR sky130_fd_sc_hd__tapvpwrvgnd_1
X_4913_ _5657_/B _3762_/X _4910_/Y _6997_/D _5061_/S VGND VGND VPWR VPWR _4913_/X
+ sky130_fd_sc_hd__o32a_2
XFILLER_21_602 VGND VGND VPWR VPWR sky130_fd_sc_hd__decap_3
XFILLER_20_112 VGND VGND VPWR VPWR sky130_fd_sc_hd__decap_3
XFILLER_21_635 VGND VGND VPWR VPWR sky130_fd_sc_hd__decap_3
X_4844_ _4633_/A _4111_/B _4842_/X _4843_/Y _4948_/A VGND VGND VPWR VPWR _4855_/A
+ sky130_fd_sc_hd__a311oi_2
X_4775_ _4775_/A _4775_/B VGND VGND VPWR VPWR _7004_/D sky130_fd_sc_hd__nor2_2
XFILLER_20_189 VGND VGND VPWR VPWR sky130_fd_sc_hd__decap_3
X_6514_ _6645_/A VGND VGND VPWR VPWR _6514_/Y sky130_fd_sc_hd__inv_2
X_3726_ _3714_/X _3721_/X _3724_/X _3725_/X VGND VGND VPWR VPWR _3726_/X sky130_fd_sc_hd__a22o_2
XFILLER_9_190 VGND VGND VPWR VPWR sky130_fd_sc_hd__decap_3
X_6445_ _6609_/A VGND VGND VPWR VPWR _6445_/Y sky130_fd_sc_hd__inv_2
X_6376_ _6603_/A VGND VGND VPWR VPWR _6376_/Y sky130_fd_sc_hd__inv_2
XFILLER_88_635 VGND VGND VPWR VPWR sky130_fd_sc_hd__decap_3
X_5327_ _5327_/A0 _4978_/X _5333_/S VGND VGND VPWR VPWR _7167_/D sky130_fd_sc_hd__mux2_2
XFILLER_0_539 VGND VGND VPWR VPWR sky130_fd_sc_hd__decap_3
XFILLER_87_134 VGND VGND VPWR VPWR sky130_fd_sc_hd__decap_3
XFILLER_75_307 VGND VGND VPWR VPWR sky130_fd_sc_hd__decap_3
XFILLER_87_167 VGND VGND VPWR VPWR sky130_fd_sc_hd__fill_1
XFILLER_87_178 VGND VGND VPWR VPWR sky130_fd_sc_hd__decap_3
X_5258_ _5258_/A0 _4945_/X _5276_/S VGND VGND VPWR VPWR _7201_/D sky130_fd_sc_hd__mux2_2
XFILLER_56_521 VGND VGND VPWR VPWR sky130_fd_sc_hd__fill_2
X_4209_ _4633_/A _4903_/A _4845_/A _4890_/B VGND VGND VPWR VPWR _4384_/A sky130_fd_sc_hd__and4_2
XFILLER_28_245 VGND VGND VPWR VPWR sky130_fd_sc_hd__decap_3
XFILLER_28_256 VGND VGND VPWR VPWR sky130_fd_sc_hd__decap_3
XFILLER_56_554 VGND VGND VPWR VPWR sky130_fd_sc_hd__decap_3
XFILLER_83_340 VGND VGND VPWR VPWR sky130_fd_sc_hd__decap_3
XFILLER_28_289 VGND VGND VPWR VPWR sky130_fd_sc_hd__decap_3
XFILLER_83_373 VGND VGND VPWR VPWR sky130_fd_sc_hd__decap_3
XFILLER_12_613 VGND VGND VPWR VPWR sky130_fd_sc_hd__decap_3
XFILLER_24_495 VGND VGND VPWR VPWR sky130_fd_sc_hd__decap_3
XFILLER_51_270 VGND VGND VPWR VPWR sky130_fd_sc_hd__decap_3
XFILLER_51_281 VGND VGND VPWR VPWR sky130_fd_sc_hd__decap_3
XFILLER_11_156 VGND VGND VPWR VPWR sky130_fd_sc_hd__decap_3
XFILLER_8_628 VGND VGND VPWR VPWR sky130_fd_sc_hd__decap_3
XFILLER_11_178 VGND VGND VPWR VPWR sky130_fd_sc_hd__decap_3
XFILLER_22_85 VGND VGND VPWR VPWR sky130_fd_sc_hd__decap_3
XFILLER_3_300 VGND VGND VPWR VPWR sky130_fd_sc_hd__decap_3
XFILLER_3_333 VGND VGND VPWR VPWR sky130_fd_sc_hd__decap_3
XFILLER_3_366 VGND VGND VPWR VPWR sky130_fd_sc_hd__decap_3
XFILLER_79_613 VGND VGND VPWR VPWR sky130_fd_sc_hd__decap_3
XFILLER_78_123 VGND VGND VPWR VPWR sky130_fd_sc_hd__decap_3
XFILLER_66_318 VGND VGND VPWR VPWR sky130_fd_sc_hd__decap_3
XFILLER_94_627 VGND VGND VPWR VPWR sky130_fd_sc_hd__decap_3
XFILLER_19_245 VGND VGND VPWR VPWR sky130_fd_sc_hd__decap_3
XFILLER_19_289 VGND VGND VPWR VPWR sky130_fd_sc_hd__fill_1
XFILLER_62_557 VGND VGND VPWR VPWR sky130_fd_sc_hd__fill_2
XTAP_TAPCELL_ROW_45_755 VGND VPWR sky130_fd_sc_hd__tapvpwrvgnd_1
XTAP_TAPCELL_ROW_17_435 VGND VPWR sky130_fd_sc_hd__tapvpwrvgnd_1
XFILLER_15_495 VGND VGND VPWR VPWR sky130_fd_sc_hd__decap_3
XFILLER_42_270 VGND VGND VPWR VPWR sky130_fd_sc_hd__decap_3
XFILLER_42_281 VGND VGND VPWR VPWR sky130_fd_sc_hd__decap_3
XFILLER_30_443 VGND VGND VPWR VPWR sky130_fd_sc_hd__decap_3
XFILLER_30_465 VGND VGND VPWR VPWR sky130_fd_sc_hd__decap_3
XFILLER_6_160 VGND VGND VPWR VPWR sky130_fd_sc_hd__decap_3
Xhold606 _6827_/Q VGND VGND VPWR VPWR _6827_/D sky130_fd_sc_hd__dlygate4sd3_1
Xhold617 _6736_/Q VGND VGND VPWR VPWR _6736_/D sky130_fd_sc_hd__dlygate4sd3_1
Xwire570 _3371_/Y VGND VGND VPWR VPWR _3399_/A sky130_fd_sc_hd__clkdlybuf4s25_1
X_4491_ _4491_/A0 _7302_/Q _4501_/S VGND VGND VPWR VPWR _7334_/D sky130_fd_sc_hd__mux2_2
XTAP_TAPCELL_ROW_77_1123 VGND VPWR sky130_fd_sc_hd__tapvpwrvgnd_1
XFILLER_6_193 VGND VGND VPWR VPWR sky130_fd_sc_hd__decap_3
Xhold628 _6882_/Q VGND VGND VPWR VPWR _6882_/D sky130_fd_sc_hd__dlygate4sd3_1
Xhold639 _6779_/Q VGND VGND VPWR VPWR _6779_/D sky130_fd_sc_hd__dlygate4sd3_1
X_3442_ _3874_/A _3442_/B VGND VGND VPWR VPWR _4394_/A sky130_fd_sc_hd__nand2_2
X_3373_ _3560_/B _3370_/Y _4471_/S VGND VGND VPWR VPWR _3429_/A sky130_fd_sc_hd__a21o_2
X_5112_ _4292_/A _3594_/B _4295_/X VGND VGND VPWR VPWR _5113_/B sky130_fd_sc_hd__a21oi_2
XFILLER_69_156 VGND VGND VPWR VPWR sky130_fd_sc_hd__decap_3
XFILLER_97_476 VGND VGND VPWR VPWR sky130_fd_sc_hd__decap_3
XFILLER_38_510 VGND VGND VPWR VPWR sky130_fd_sc_hd__fill_1
X_5043_ _6988_/Q _5066_/A VGND VGND VPWR VPWR _5044_/B sky130_fd_sc_hd__nor2_2
XFILLER_97_498 VGND VGND VPWR VPWR sky130_fd_sc_hd__decap_3
XTAP_TAPCELL_ROW_88_1241 VGND VPWR sky130_fd_sc_hd__tapvpwrvgnd_1
XTAP_TAPCELL_ROW_88_1252 VGND VPWR sky130_fd_sc_hd__tapvpwrvgnd_1
XFILLER_25_237 VGND VGND VPWR VPWR sky130_fd_sc_hd__decap_3
XFILLER_53_535 VGND VGND VPWR VPWR sky130_fd_sc_hd__decap_3
X_6994_ _7397_/CLK _6994_/D _6274_/Y VGND VGND VPWR VPWR _6994_/Q sky130_fd_sc_hd__dfrtp_2
XFILLER_33_281 VGND VGND VPWR VPWR sky130_fd_sc_hd__decap_3
XFILLER_40_218 VGND VGND VPWR VPWR sky130_fd_sc_hd__decap_3
XFILLER_80_398 VGND VGND VPWR VPWR sky130_fd_sc_hd__decap_3
XFILLER_21_443 VGND VGND VPWR VPWR sky130_fd_sc_hd__decap_3
X_4827_ _4827_/A _4827_/B VGND VGND VPWR VPWR _4827_/X sky130_fd_sc_hd__xor2_2
XFILLER_5_609 VGND VGND VPWR VPWR sky130_fd_sc_hd__decap_3
X_4758_ _7004_/Q _4804_/A VGND VGND VPWR VPWR _4777_/B sky130_fd_sc_hd__nand2_2
XTAP_TAPCELL_ROW_99_1370 VGND VPWR sky130_fd_sc_hd__tapvpwrvgnd_1
X_4689_ _7002_/Q _4834_/A _4688_/X _7003_/Q VGND VGND VPWR VPWR _4804_/A sky130_fd_sc_hd__o211a_2
X_3709_ _3682_/A _3708_/X _5104_/A VGND VGND VPWR VPWR _3709_/X sky130_fd_sc_hd__a21o_2
XFILLER_108_44 VGND VGND VPWR VPWR sky130_fd_sc_hd__fill_1
X_6428_ _6557_/A VGND VGND VPWR VPWR _6428_/Y sky130_fd_sc_hd__inv_2
XFILLER_108_66 VGND VGND VPWR VPWR sky130_fd_sc_hd__decap_3
XFILLER_108_77 VGND VGND VPWR VPWR sky130_fd_sc_hd__decap_3
XFILLER_102_220 VGND VGND VPWR VPWR sky130_fd_sc_hd__decap_3
XFILLER_108_88 VGND VGND VPWR VPWR sky130_fd_sc_hd__decap_3
XFILLER_88_421 VGND VGND VPWR VPWR sky130_fd_sc_hd__decap_3
X_6359_ _6364_/A VGND VGND VPWR VPWR _6359_/Y sky130_fd_sc_hd__inv_2
XFILLER_102_253 VGND VGND VPWR VPWR sky130_fd_sc_hd__decap_3
XFILLER_88_454 VGND VGND VPWR VPWR sky130_fd_sc_hd__decap_3
XFILLER_48_318 VGND VGND VPWR VPWR sky130_fd_sc_hd__decap_3
XFILLER_48_329 VGND VGND VPWR VPWR sky130_fd_sc_hd__decap_3
XFILLER_75_126 VGND VGND VPWR VPWR sky130_fd_sc_hd__decap_3
XFILLER_76_638 VGND VGND VPWR VPWR sky130_fd_sc_hd__decap_3
XFILLER_75_148 VGND VGND VPWR VPWR sky130_fd_sc_hd__decap_3
XFILLER_84_25 VGND VGND VPWR VPWR sky130_fd_sc_hd__decap_3
XFILLER_29_587 VGND VGND VPWR VPWR sky130_fd_sc_hd__decap_3
XFILLER_56_362 VGND VGND VPWR VPWR sky130_fd_sc_hd__fill_2
XFILLER_90_118 VGND VGND VPWR VPWR sky130_fd_sc_hd__fill_2
XFILLER_17_63 VGND VGND VPWR VPWR sky130_fd_sc_hd__decap_3
XFILLER_44_557 VGND VGND VPWR VPWR sky130_fd_sc_hd__decap_3
XFILLER_71_343 VGND VGND VPWR VPWR sky130_fd_sc_hd__decap_3
XFILLER_83_181 VGND VGND VPWR VPWR sky130_fd_sc_hd__decap_3
XFILLER_16_259 VGND VGND VPWR VPWR sky130_fd_sc_hd__decap_3
XFILLER_17_85 VGND VGND VPWR VPWR sky130_fd_sc_hd__decap_3
XFILLER_44_579 VGND VGND VPWR VPWR sky130_fd_sc_hd__decap_3
XTAP_TAPCELL_ROW_42_714 VGND VPWR sky130_fd_sc_hd__tapvpwrvgnd_1
XFILLER_12_432 VGND VGND VPWR VPWR sky130_fd_sc_hd__decap_3
XFILLER_24_292 VGND VGND VPWR VPWR sky130_fd_sc_hd__fill_2
XFILLER_33_84 VGND VGND VPWR VPWR sky130_fd_sc_hd__decap_3
XTAP_TAPCELL_ROW_22_493 VGND VPWR sky130_fd_sc_hd__tapvpwrvgnd_1
XTAP_TAPCELL_ROW_22_482 VGND VPWR sky130_fd_sc_hd__tapvpwrvgnd_1
XFILLER_4_631 VGND VGND VPWR VPWR sky130_fd_sc_hd__decap_3
XFILLER_3_152 VGND VGND VPWR VPWR sky130_fd_sc_hd__decap_3
XFILLER_98_218 VGND VGND VPWR VPWR sky130_fd_sc_hd__decap_3
XFILLER_106_581 VGND VGND VPWR VPWR sky130_fd_sc_hd__decap_3
XFILLER_79_476 VGND VGND VPWR VPWR sky130_fd_sc_hd__decap_3
XFILLER_94_402 VGND VGND VPWR VPWR sky130_fd_sc_hd__decap_3
XTAP_TAPCELL_ROW_72_1064 VGND VPWR sky130_fd_sc_hd__tapvpwrvgnd_1
XFILLER_39_318 VGND VGND VPWR VPWR sky130_fd_sc_hd__fill_1
XFILLER_94_424 VGND VGND VPWR VPWR sky130_fd_sc_hd__fill_2
XFILLER_94_468 VGND VGND VPWR VPWR sky130_fd_sc_hd__fill_2
XFILLER_81_129 VGND VGND VPWR VPWR sky130_fd_sc_hd__decap_3
XFILLER_90_630 VGND VGND VPWR VPWR sky130_fd_sc_hd__decap_3
XFILLER_62_376 VGND VGND VPWR VPWR sky130_fd_sc_hd__decap_3
X_3991_ _5151_/A _3991_/B VGND VGND VPWR VPWR _3991_/X sky130_fd_sc_hd__or2_2
XFILLER_22_229 VGND VGND VPWR VPWR sky130_fd_sc_hd__decap_3
XFILLER_95_3 VGND VGND VPWR VPWR sky130_fd_sc_hd__decap_3
XTAP_TAPCELL_ROW_83_1193 VGND VPWR sky130_fd_sc_hd__tapvpwrvgnd_1
XFILLER_30_262 VGND VGND VPWR VPWR sky130_fd_sc_hd__decap_3
XFILLER_90_90 VGND VGND VPWR VPWR sky130_fd_sc_hd__decap_3
X_7400_ _7406_/CLK _7400_/D _6680_/Y VGND VGND VPWR VPWR _7400_/Q sky130_fd_sc_hd__dfrtp_2
X_5661_ _5661_/A _5661_/B _5661_/C _5661_/D VGND VGND VPWR VPWR _5661_/X sky130_fd_sc_hd__and4_2
X_4612_ _4612_/A _4612_/B VGND VGND VPWR VPWR _5114_/B sky130_fd_sc_hd__nor2_2
X_7331_ _7366_/CLK _7331_/D _6611_/Y VGND VGND VPWR VPWR _7331_/Q sky130_fd_sc_hd__dfrtp_2
X_7262_ _7357_/CLK _7262_/D _6542_/Y VGND VGND VPWR VPWR _7262_/Q sky130_fd_sc_hd__dfrtp_2
XFILLER_104_507 VGND VGND VPWR VPWR sky130_fd_sc_hd__decap_3
XFILLER_89_207 VGND VGND VPWR VPWR sky130_fd_sc_hd__decap_3
X_4474_ _4474_/A0 _4540_/A _4501_/S VGND VGND VPWR VPWR _7342_/D sky130_fd_sc_hd__mux2_2
X_7193_ _7280_/CLK _7193_/D _6473_/Y VGND VGND VPWR VPWR _7193_/Q sky130_fd_sc_hd__dfrtp_2
X_3425_ _3589_/A _3586_/A _3589_/B _3590_/C VGND VGND VPWR VPWR _3527_/A sky130_fd_sc_hd__o31a_2
XFILLER_58_616 VGND VGND VPWR VPWR sky130_fd_sc_hd__decap_3
X_3356_ _5118_/D _3354_/X _3355_/Y _3561_/A VGND VGND VPWR VPWR _4537_/B sky130_fd_sc_hd__a22o_2
XFILLER_97_240 VGND VGND VPWR VPWR sky130_fd_sc_hd__decap_3
XFILLER_38_29 VGND VGND VPWR VPWR sky130_fd_sc_hd__decap_3
XFILLER_85_424 VGND VGND VPWR VPWR sky130_fd_sc_hd__decap_3
Xhold1103 _7323_/Q VGND VGND VPWR VPWR _4513_/A0 sky130_fd_sc_hd__dlygate4sd3_1
Xhold1114 _7159_/Q VGND VGND VPWR VPWR _5344_/A0 sky130_fd_sc_hd__dlygate4sd3_1
XFILLER_57_137 VGND VGND VPWR VPWR sky130_fd_sc_hd__decap_3
Xhold1125 _7129_/Q VGND VGND VPWR VPWR _5409_/A0 sky130_fd_sc_hd__dlygate4sd3_1
Xhold1136 _7128_/Q VGND VGND VPWR VPWR _5411_/A0 sky130_fd_sc_hd__dlygate4sd3_1
Xhold1147 _7151_/Q VGND VGND VPWR VPWR _5360_/A0 sky130_fd_sc_hd__dlygate4sd3_1
Xhold1158 _7226_/Q VGND VGND VPWR VPWR _5205_/A sky130_fd_sc_hd__dlygate4sd3_1
X_5026_ _5026_/A _5026_/B VGND VGND VPWR VPWR _6990_/D sky130_fd_sc_hd__nor2_2
XFILLER_26_502 VGND VGND VPWR VPWR sky130_fd_sc_hd__decap_3
Xhold1169 _7398_/Q VGND VGND VPWR VPWR _3750_/A1 sky130_fd_sc_hd__dlygate4sd3_1
XFILLER_65_181 VGND VGND VPWR VPWR sky130_fd_sc_hd__decap_3
XFILLER_81_641 VGND VGND VPWR VPWR sky130_fd_sc_hd__decap_3
XFILLER_13_207 VGND VGND VPWR VPWR sky130_fd_sc_hd__decap_3
XFILLER_26_557 VGND VGND VPWR VPWR sky130_fd_sc_hd__decap_3
XFILLER_41_505 VGND VGND VPWR VPWR sky130_fd_sc_hd__fill_2
XFILLER_53_343 VGND VGND VPWR VPWR sky130_fd_sc_hd__fill_1
XFILLER_80_151 VGND VGND VPWR VPWR sky130_fd_sc_hd__decap_3
X_6977_ clkload6/A _6977_/D VGND VGND VPWR VPWR _6977_/Q sky130_fd_sc_hd__dfxtp_2
XFILLER_41_527 VGND VGND VPWR VPWR sky130_fd_sc_hd__fill_1
XFILLER_80_184 VGND VGND VPWR VPWR sky130_fd_sc_hd__decap_3
XFILLER_21_284 VGND VGND VPWR VPWR sky130_fd_sc_hd__fill_2
XFILLER_5_428 VGND VGND VPWR VPWR sky130_fd_sc_hd__decap_3
XFILLER_107_334 VGND VGND VPWR VPWR sky130_fd_sc_hd__fill_2
XFILLER_1_623 VGND VGND VPWR VPWR sky130_fd_sc_hd__decap_3
Xhold981 _7395_/Q VGND VGND VPWR VPWR hold981/X sky130_fd_sc_hd__dlygate4sd3_1
Xhold970 _7024_/Q VGND VGND VPWR VPWR _5607_/A sky130_fd_sc_hd__dlygate4sd3_1
XFILLER_103_551 VGND VGND VPWR VPWR sky130_fd_sc_hd__decap_3
Xhold992 _7183_/Q VGND VGND VPWR VPWR hold992/X sky130_fd_sc_hd__dlygate4sd3_1
XFILLER_0_155 VGND VGND VPWR VPWR sky130_fd_sc_hd__decap_3
XFILLER_0_177 VGND VGND VPWR VPWR sky130_fd_sc_hd__decap_3
XFILLER_103_573 VGND VGND VPWR VPWR sky130_fd_sc_hd__decap_3
XFILLER_49_638 VGND VGND VPWR VPWR sky130_fd_sc_hd__decap_3
XFILLER_76_435 VGND VGND VPWR VPWR sky130_fd_sc_hd__decap_3
XFILLER_88_262 VGND VGND VPWR VPWR sky130_fd_sc_hd__decap_3
XFILLER_95_35 VGND VGND VPWR VPWR sky130_fd_sc_hd__fill_2
XFILLER_95_57 VGND VGND VPWR VPWR sky130_fd_sc_hd__decap_3
XFILLER_76_468 VGND VGND VPWR VPWR sky130_fd_sc_hd__fill_2
XFILLER_28_73 VGND VGND VPWR VPWR sky130_fd_sc_hd__decap_3
XFILLER_29_340 VGND VGND VPWR VPWR sky130_fd_sc_hd__fill_1
XFILLER_29_351 VGND VGND VPWR VPWR sky130_fd_sc_hd__fill_2
XFILLER_91_405 VGND VGND VPWR VPWR sky130_fd_sc_hd__decap_3
XFILLER_91_416 VGND VGND VPWR VPWR sky130_fd_sc_hd__decap_3
XFILLER_17_535 VGND VGND VPWR VPWR sky130_fd_sc_hd__fill_1
XFILLER_91_449 VGND VGND VPWR VPWR sky130_fd_sc_hd__decap_3
XFILLER_32_505 VGND VGND VPWR VPWR sky130_fd_sc_hd__decap_3
XFILLER_71_140 VGND VGND VPWR VPWR sky130_fd_sc_hd__decap_3
XTAP_TAPCELL_ROW_27_541 VGND VPWR sky130_fd_sc_hd__tapvpwrvgnd_1
XTAP_TAPCELL_ROW_106_1458 VGND VPWR sky130_fd_sc_hd__tapvpwrvgnd_1
XFILLER_44_387 VGND VGND VPWR VPWR sky130_fd_sc_hd__decap_3
XFILLER_44_61 VGND VGND VPWR VPWR sky130_fd_sc_hd__decap_3
XTAP_TAPCELL_ROW_55_872 VGND VPWR sky130_fd_sc_hd__tapvpwrvgnd_1
XFILLER_44_94 VGND VGND VPWR VPWR sky130_fd_sc_hd__decap_3
XFILLER_12_251 VGND VGND VPWR VPWR sky130_fd_sc_hd__fill_1
XFILLER_12_262 VGND VGND VPWR VPWR sky130_fd_sc_hd__decap_3
XFILLER_8_200 VGND VGND VPWR VPWR sky130_fd_sc_hd__decap_3
XFILLER_12_284 VGND VGND VPWR VPWR sky130_fd_sc_hd__decap_3
XFILLER_8_233 VGND VGND VPWR VPWR sky130_fd_sc_hd__decap_3
XFILLER_60_60 VGND VGND VPWR VPWR sky130_fd_sc_hd__decap_3
XFILLER_60_82 VGND VGND VPWR VPWR sky130_fd_sc_hd__fill_2
XFILLER_8_299 VGND VGND VPWR VPWR sky130_fd_sc_hd__decap_3
Xoutput508 _4791_/C1 VGND VGND VPWR VPWR instruction_out[2] sky130_fd_sc_hd__clkdlybuf4s25_1
XFILLER_4_461 VGND VGND VPWR VPWR sky130_fd_sc_hd__decap_3
XFILLER_5_55 VGND VGND VPWR VPWR sky130_fd_sc_hd__fill_1
Xoutput519 _6988_/Q VGND VGND VPWR VPWR pc_out[11] sky130_fd_sc_hd__clkdlybuf4s25_1
XFILLER_99_505 VGND VGND VPWR VPWR sky130_fd_sc_hd__decap_3
XFILLER_4_494 VGND VGND VPWR VPWR sky130_fd_sc_hd__decap_3
X_4190_ _7263_/Q _4190_/A2 _4428_/B1 _7135_/Q _4189_/X VGND VGND VPWR VPWR _4637_/B
+ sky130_fd_sc_hd__a221o_2
XFILLER_67_402 VGND VGND VPWR VPWR sky130_fd_sc_hd__decap_3
XFILLER_79_262 VGND VGND VPWR VPWR sky130_fd_sc_hd__decap_3
XFILLER_79_284 VGND VGND VPWR VPWR sky130_fd_sc_hd__decap_3
XFILLER_82_405 VGND VGND VPWR VPWR sky130_fd_sc_hd__fill_2
XFILLER_82_427 VGND VGND VPWR VPWR sky130_fd_sc_hd__decap_3
XFILLER_94_287 VGND VGND VPWR VPWR sky130_fd_sc_hd__decap_3
XFILLER_54_129 VGND VGND VPWR VPWR sky130_fd_sc_hd__fill_1
XFILLER_63_641 VGND VGND VPWR VPWR sky130_fd_sc_hd__decap_3
X_6900_ _6966_/CLK _6900_/D VGND VGND VPWR VPWR _6900_/Q sky130_fd_sc_hd__dfxtp_2
XTAP_TAPCELL_ROW_85_1211 VGND VPWR sky130_fd_sc_hd__tapvpwrvgnd_1
XFILLER_23_505 VGND VGND VPWR VPWR sky130_fd_sc_hd__decap_3
XFILLER_47_192 VGND VGND VPWR VPWR sky130_fd_sc_hd__decap_3
XFILLER_62_151 VGND VGND VPWR VPWR sky130_fd_sc_hd__fill_1
X_6831_ clkload7/A _6831_/D VGND VGND VPWR VPWR _6831_/Q sky130_fd_sc_hd__dfxtp_2
XFILLER_35_376 VGND VGND VPWR VPWR sky130_fd_sc_hd__decap_3
XFILLER_62_173 VGND VGND VPWR VPWR sky130_fd_sc_hd__decap_3
XFILLER_90_471 VGND VGND VPWR VPWR sky130_fd_sc_hd__fill_2
X_6762_ _6976_/CLK _6762_/D VGND VGND VPWR VPWR _6762_/Q sky130_fd_sc_hd__dfxtp_2
XFILLER_50_368 VGND VGND VPWR VPWR sky130_fd_sc_hd__decap_3
X_6693_ clkload4/A _6693_/D VGND VGND VPWR VPWR _6693_/Q sky130_fd_sc_hd__dfxtp_2
X_5644_ _6981_/Q _5130_/C _3340_/B _3327_/B VGND VGND VPWR VPWR _5644_/X sky130_fd_sc_hd__o211a_2
XFILLER_108_109 VGND VGND VPWR VPWR sky130_fd_sc_hd__decap_3
X_7314_ _7348_/CLK _7314_/D _6594_/Y VGND VGND VPWR VPWR _7314_/Q sky130_fd_sc_hd__dfrtp_2
X_5575_ hold955/X _5647_/A _5010_/D VGND VGND VPWR VPWR _7042_/D sky130_fd_sc_hd__a21o_2
XTAP_TAPCELL_ROW_96_1340 VGND VPWR sky130_fd_sc_hd__tapvpwrvgnd_1
X_4526_ _4526_/A0 _7284_/Q _4528_/B VGND VGND VPWR VPWR _7316_/D sky130_fd_sc_hd__mux2_2
X_7245_ _7373_/CLK _7245_/D _6525_/Y VGND VGND VPWR VPWR _7245_/Q sky130_fd_sc_hd__dfrtp_2
X_4457_ _4720_/A _4720_/B _4456_/X VGND VGND VPWR VPWR _4457_/X sky130_fd_sc_hd__o21a_2
X_7176_ _7363_/CLK _7176_/D _6456_/Y VGND VGND VPWR VPWR _7176_/Q sky130_fd_sc_hd__dfrtp_2
XFILLER_105_23 VGND VGND VPWR VPWR sky130_fd_sc_hd__decap_3
X_4388_ _7273_/Q _4437_/A2 _4385_/X _4387_/X VGND VGND VPWR VPWR _4388_/X sky130_fd_sc_hd__a211o_2
XFILLER_98_571 VGND VGND VPWR VPWR sky130_fd_sc_hd__decap_3
XFILLER_46_608 VGND VGND VPWR VPWR sky130_fd_sc_hd__decap_3
X_3339_ _3319_/X _5238_/B _3329_/Y _3339_/C1 VGND VGND VPWR VPWR _3339_/Y sky130_fd_sc_hd__a211oi_2
XFILLER_58_468 VGND VGND VPWR VPWR sky130_fd_sc_hd__decap_3
XFILLER_73_405 VGND VGND VPWR VPWR sky130_fd_sc_hd__decap_3
XFILLER_85_265 VGND VGND VPWR VPWR sky130_fd_sc_hd__decap_3
XFILLER_26_321 VGND VGND VPWR VPWR sky130_fd_sc_hd__fill_1
X_5009_ _5009_/A _5009_/B VGND VGND VPWR VPWR _5010_/D sky130_fd_sc_hd__nor2_2
XFILLER_26_332 VGND VGND VPWR VPWR sky130_fd_sc_hd__decap_3
XFILLER_54_641 VGND VGND VPWR VPWR sky130_fd_sc_hd__decap_3
XFILLER_26_398 VGND VGND VPWR VPWR sky130_fd_sc_hd__fill_2
XFILLER_41_302 VGND VGND VPWR VPWR sky130_fd_sc_hd__decap_3
XFILLER_53_162 VGND VGND VPWR VPWR sky130_fd_sc_hd__decap_3
XFILLER_53_184 VGND VGND VPWR VPWR sky130_fd_sc_hd__decap_3
XFILLER_81_482 VGND VGND VPWR VPWR sky130_fd_sc_hd__decap_3
XTAP_TAPCELL_ROW_24_511 VGND VPWR sky130_fd_sc_hd__tapvpwrvgnd_1
XFILLER_41_335 VGND VGND VPWR VPWR sky130_fd_sc_hd__fill_1
XTAP_TAPCELL_ROW_52_831 VGND VPWR sky130_fd_sc_hd__tapvpwrvgnd_1
XTAP_TAPCELL_ROW_101_1399 VGND VPWR sky130_fd_sc_hd__tapvpwrvgnd_1
XFILLER_108_632 VGND VGND VPWR VPWR sky130_fd_sc_hd__decap_3
XFILLER_107_153 VGND VGND VPWR VPWR sky130_fd_sc_hd__fill_1
XFILLER_5_269 VGND VGND VPWR VPWR sky130_fd_sc_hd__decap_3
XFILLER_107_175 VGND VGND VPWR VPWR sky130_fd_sc_hd__decap_3
XFILLER_1_442 VGND VGND VPWR VPWR sky130_fd_sc_hd__fill_1
XFILLER_103_370 VGND VGND VPWR VPWR sky130_fd_sc_hd__decap_3
XFILLER_39_50 VGND VGND VPWR VPWR sky130_fd_sc_hd__decap_3
XFILLER_39_72 VGND VGND VPWR VPWR sky130_fd_sc_hd__decap_3
XFILLER_76_221 VGND VGND VPWR VPWR sky130_fd_sc_hd__fill_2
XFILLER_76_232 VGND VGND VPWR VPWR sky130_fd_sc_hd__decap_3
XFILLER_64_416 VGND VGND VPWR VPWR sky130_fd_sc_hd__decap_3
XFILLER_76_265 VGND VGND VPWR VPWR sky130_fd_sc_hd__decap_3
XFILLER_17_310 VGND VGND VPWR VPWR sky130_fd_sc_hd__decap_3
XFILLER_17_321 VGND VGND VPWR VPWR sky130_fd_sc_hd__decap_3
XFILLER_29_181 VGND VGND VPWR VPWR sky130_fd_sc_hd__decap_3
XFILLER_64_438 VGND VGND VPWR VPWR sky130_fd_sc_hd__fill_1
XTAP_TAPCELL_ROW_4_280 VGND VPWR sky130_fd_sc_hd__tapvpwrvgnd_1
XPHY_EDGE_ROW_101_Right_101 VGND VGND VPWR VPWR sky130_fd_sc_hd__decap_3
XFILLER_45_641 VGND VGND VPWR VPWR sky130_fd_sc_hd__decap_3
XFILLER_55_60 VGND VGND VPWR VPWR sky130_fd_sc_hd__decap_3
XFILLER_91_246 VGND VGND VPWR VPWR sky130_fd_sc_hd__decap_3
XFILLER_91_279 VGND VGND VPWR VPWR sky130_fd_sc_hd__fill_1
XFILLER_44_162 VGND VGND VPWR VPWR sky130_fd_sc_hd__decap_3
XFILLER_32_335 VGND VGND VPWR VPWR sky130_fd_sc_hd__decap_3
XFILLER_60_633 VGND VGND VPWR VPWR sky130_fd_sc_hd__decap_3
XFILLER_32_368 VGND VGND VPWR VPWR sky130_fd_sc_hd__decap_3
XTAP_TAPCELL_ROW_80_1152 VGND VPWR sky130_fd_sc_hd__tapvpwrvgnd_1
XFILLER_13_582 VGND VGND VPWR VPWR sky130_fd_sc_hd__decap_3
XFILLER_9_564 VGND VGND VPWR VPWR sky130_fd_sc_hd__decap_3
XFILLER_9_597 VGND VGND VPWR VPWR sky130_fd_sc_hd__decap_3
X_5360_ _5360_/A0 _4470_/X _7412_/A VGND VGND VPWR VPWR _7151_/D sky130_fd_sc_hd__mux2_2
X_4311_ _4311_/A _4311_/B _4311_/C VGND VGND VPWR VPWR _4311_/X sky130_fd_sc_hd__or3_2
XFILLER_4_291 VGND VGND VPWR VPWR sky130_fd_sc_hd__decap_3
X_7030_ _7348_/CLK _7030_/D _6310_/Y VGND VGND VPWR VPWR _7030_/Q sky130_fd_sc_hd__dfrtp_2
XFILLER_101_318 VGND VGND VPWR VPWR sky130_fd_sc_hd__fill_1
XTAP_TAPCELL_ROW_91_1281 VGND VPWR sky130_fd_sc_hd__tapvpwrvgnd_1
X_4173_ _7072_/Q VGND VGND VPWR VPWR _4173_/Y sky130_fd_sc_hd__inv_2
XFILLER_28_619 VGND VGND VPWR VPWR sky130_fd_sc_hd__decap_3
XFILLER_55_427 VGND VGND VPWR VPWR sky130_fd_sc_hd__decap_3
XFILLER_55_438 VGND VGND VPWR VPWR sky130_fd_sc_hd__decap_3
XFILLER_55_449 VGND VGND VPWR VPWR sky130_fd_sc_hd__decap_3
XFILLER_67_287 VGND VGND VPWR VPWR sky130_fd_sc_hd__fill_1
XFILLER_82_213 VGND VGND VPWR VPWR sky130_fd_sc_hd__decap_3
XFILLER_36_641 VGND VGND VPWR VPWR sky130_fd_sc_hd__decap_3
XFILLER_82_268 VGND VGND VPWR VPWR sky130_fd_sc_hd__decap_3
XTAP_TAPCELL_ROW_66_989 VGND VPWR sky130_fd_sc_hd__tapvpwrvgnd_1
XTAP_TAPCELL_ROW_38_669 VGND VPWR sky130_fd_sc_hd__tapvpwrvgnd_1
XFILLER_35_151 VGND VGND VPWR VPWR sky130_fd_sc_hd__decap_3
XFILLER_51_611 VGND VGND VPWR VPWR sky130_fd_sc_hd__decap_3
XFILLER_70_419 VGND VGND VPWR VPWR sky130_fd_sc_hd__fill_1
XFILLER_50_121 VGND VGND VPWR VPWR sky130_fd_sc_hd__decap_3
XFILLER_51_644 VGND VGND VPWR VPWR sky130_fd_sc_hd__decap_3
X_6814_ _6966_/CLK _6814_/D VGND VGND VPWR VPWR _6814_/Q sky130_fd_sc_hd__dfxtp_2
XFILLER_11_519 VGND VGND VPWR VPWR sky130_fd_sc_hd__decap_3
XFILLER_23_379 VGND VGND VPWR VPWR sky130_fd_sc_hd__decap_3
XFILLER_50_165 VGND VGND VPWR VPWR sky130_fd_sc_hd__fill_1
X_6745_ _6958_/CLK _6745_/D VGND VGND VPWR VPWR _6745_/Q sky130_fd_sc_hd__dfxtp_2
X_6676_ _6680_/A VGND VGND VPWR VPWR _6676_/Y sky130_fd_sc_hd__inv_2
X_3888_ _6844_/Q _3888_/A2 _3665_/X _6839_/Q VGND VGND VPWR VPWR _3888_/X sky130_fd_sc_hd__a22o_2
XFILLER_105_635 VGND VGND VPWR VPWR sky130_fd_sc_hd__decap_3
X_4509_ hold979/X _3398_/Y _4244_/X VGND VGND VPWR VPWR _7325_/D sky130_fd_sc_hd__a21o_2
XFILLER_104_156 VGND VGND VPWR VPWR sky130_fd_sc_hd__decap_3
XFILLER_2_239 VGND VGND VPWR VPWR sky130_fd_sc_hd__decap_3
X_7228_ _7280_/CLK _7228_/D _6508_/Y VGND VGND VPWR VPWR _7228_/Q sky130_fd_sc_hd__dfrtp_2
X_7159_ _7280_/CLK _7159_/D _6439_/Y VGND VGND VPWR VPWR _7159_/Q sky130_fd_sc_hd__dfrtp_2
XFILLER_100_340 VGND VGND VPWR VPWR sky130_fd_sc_hd__decap_3
XFILLER_86_585 VGND VGND VPWR VPWR sky130_fd_sc_hd__decap_3
XFILLER_18_129 VGND VGND VPWR VPWR sky130_fd_sc_hd__fill_2
XFILLER_73_213 VGND VGND VPWR VPWR sky130_fd_sc_hd__decap_3
XFILLER_86_596 VGND VGND VPWR VPWR sky130_fd_sc_hd__fill_2
XFILLER_27_641 VGND VGND VPWR VPWR sky130_fd_sc_hd__decap_3
XFILLER_61_408 VGND VGND VPWR VPWR sky130_fd_sc_hd__decap_3
XFILLER_73_268 VGND VGND VPWR VPWR sky130_fd_sc_hd__fill_2
Xclkbuf_leaf_38_clk clkbuf_3_2__f_clk/X VGND VGND VPWR VPWR _7380_/CLK sky130_fd_sc_hd__clkbuf_16
XTAP_TAPCELL_ROW_1_250 VGND VPWR sky130_fd_sc_hd__tapvpwrvgnd_1
XTAP_TAPCELL_ROW_103_1417 VGND VPWR sky130_fd_sc_hd__tapvpwrvgnd_1
XFILLER_26_195 VGND VGND VPWR VPWR sky130_fd_sc_hd__fill_1
XFILLER_42_633 VGND VGND VPWR VPWR sky130_fd_sc_hd__decap_3
XFILLER_41_187 VGND VGND VPWR VPWR sky130_fd_sc_hd__decap_3
XFILLER_41_198 VGND VGND VPWR VPWR sky130_fd_sc_hd__decap_3
XFILLER_10_574 VGND VGND VPWR VPWR sky130_fd_sc_hd__decap_3
XFILLER_41_73 VGND VGND VPWR VPWR sky130_fd_sc_hd__decap_3
XFILLER_108_440 VGND VGND VPWR VPWR sky130_fd_sc_hd__decap_3
XFILLER_6_578 VGND VGND VPWR VPWR sky130_fd_sc_hd__decap_3
XFILLER_6_589 VGND VGND VPWR VPWR sky130_fd_sc_hd__decap_3
XFILLER_1_261 VGND VGND VPWR VPWR sky130_fd_sc_hd__decap_3
XFILLER_69_519 VGND VGND VPWR VPWR sky130_fd_sc_hd__decap_3
XFILLER_2_12 VGND VGND VPWR VPWR sky130_fd_sc_hd__decap_3
XFILLER_49_221 VGND VGND VPWR VPWR sky130_fd_sc_hd__decap_3
XFILLER_77_530 VGND VGND VPWR VPWR sky130_fd_sc_hd__decap_3
XFILLER_77_541 VGND VGND VPWR VPWR sky130_fd_sc_hd__decap_3
XFILLER_37_438 VGND VGND VPWR VPWR sky130_fd_sc_hd__fill_1
XFILLER_37_449 VGND VGND VPWR VPWR sky130_fd_sc_hd__decap_3
XFILLER_92_533 VGND VGND VPWR VPWR sky130_fd_sc_hd__decap_3
XTAP_TAPCELL_ROW_69_1025 VGND VPWR sky130_fd_sc_hd__tapvpwrvgnd_1
XFILLER_64_235 VGND VGND VPWR VPWR sky130_fd_sc_hd__decap_3
XFILLER_92_577 VGND VGND VPWR VPWR sky130_fd_sc_hd__decap_3
Xclkbuf_leaf_29_clk clkbuf_3_6__f_clk/X VGND VGND VPWR VPWR _7362_/CLK sky130_fd_sc_hd__clkbuf_16
XFILLER_17_162 VGND VGND VPWR VPWR sky130_fd_sc_hd__decap_3
XFILLER_64_279 VGND VGND VPWR VPWR sky130_fd_sc_hd__decap_3
XFILLER_17_195 VGND VGND VPWR VPWR sky130_fd_sc_hd__decap_3
XFILLER_33_644 VGND VGND VPWR VPWR sky130_fd_sc_hd__decap_3
XFILLER_72_290 VGND VGND VPWR VPWR sky130_fd_sc_hd__fill_1
X_4860_ _4687_/B _4859_/Y _4777_/A VGND VGND VPWR VPWR _4860_/Y sky130_fd_sc_hd__o21ai_2
XTAP_TAPCELL_ROW_63_959 VGND VPWR sky130_fd_sc_hd__tapvpwrvgnd_1
XTAP_TAPCELL_ROW_35_639 VGND VPWR sky130_fd_sc_hd__tapvpwrvgnd_1
XFILLER_60_452 VGND VGND VPWR VPWR sky130_fd_sc_hd__decap_3
X_3811_ _3927_/A1 _3808_/X _3810_/X _3741_/X VGND VGND VPWR VPWR _3811_/X sky130_fd_sc_hd__a22o_2
XFILLER_20_316 VGND VGND VPWR VPWR sky130_fd_sc_hd__decap_3
XFILLER_32_187 VGND VGND VPWR VPWR sky130_fd_sc_hd__decap_3
X_6530_ _6594_/A VGND VGND VPWR VPWR _6530_/Y sky130_fd_sc_hd__inv_2
X_4791_ _3423_/A _5664_/A _3697_/Y _4791_/C1 VGND VGND VPWR VPWR _4791_/Y sky130_fd_sc_hd__a211oi_2
XFILLER_13_390 VGND VGND VPWR VPWR sky130_fd_sc_hd__fill_2
X_3742_ _6833_/Q _3656_/Y _3852_/B1 _6843_/Q VGND VGND VPWR VPWR _3742_/X sky130_fd_sc_hd__a22o_2
XFILLER_9_361 VGND VGND VPWR VPWR sky130_fd_sc_hd__decap_3
X_6461_ _6619_/A VGND VGND VPWR VPWR _6461_/Y sky130_fd_sc_hd__inv_2
X_3673_ _6856_/Q _6864_/Q _6904_/Q _6912_/Q _3991_/B _3665_/B VGND VGND VPWR VPWR
+ _3673_/X sky130_fd_sc_hd__mux4_2
XFILLER_9_383 VGND VGND VPWR VPWR sky130_fd_sc_hd__decap_3
X_6392_ _6622_/A VGND VGND VPWR VPWR _6392_/Y sky130_fd_sc_hd__inv_2
XFILLER_99_143 VGND VGND VPWR VPWR sky130_fd_sc_hd__decap_3
XFILLER_102_627 VGND VGND VPWR VPWR sky130_fd_sc_hd__decap_3
XFILLER_87_305 VGND VGND VPWR VPWR sky130_fd_sc_hd__decap_3
X_5274_ _5274_/A0 _5079_/X _5274_/S VGND VGND VPWR VPWR _7193_/D sky130_fd_sc_hd__mux2_2
XFILLER_101_137 VGND VGND VPWR VPWR sky130_fd_sc_hd__decap_3
XFILLER_87_349 VGND VGND VPWR VPWR sky130_fd_sc_hd__fill_2
X_7013_ _7280_/CLK _7013_/D _6293_/Y VGND VGND VPWR VPWR _7013_/Q sky130_fd_sc_hd__dfrtp_2
X_4225_ _4371_/A _4371_/B _4224_/C VGND VGND VPWR VPWR _4627_/A sky130_fd_sc_hd__a21oi_2
XFILLER_68_563 VGND VGND VPWR VPWR sky130_fd_sc_hd__decap_3
XFILLER_83_500 VGND VGND VPWR VPWR sky130_fd_sc_hd__fill_1
X_4156_ _4157_/A _4205_/C VGND VGND VPWR VPWR _4158_/A sky130_fd_sc_hd__or2_2
XFILLER_28_449 VGND VGND VPWR VPWR sky130_fd_sc_hd__decap_3
XFILLER_46_29 VGND VGND VPWR VPWR sky130_fd_sc_hd__decap_3
XFILLER_55_202 VGND VGND VPWR VPWR sky130_fd_sc_hd__decap_3
X_4087_ _7078_/Q _4102_/B _4432_/B1 _4086_/X VGND VGND VPWR VPWR _4095_/A sky130_fd_sc_hd__o211ai_2
XFILLER_102_24 VGND VGND VPWR VPWR sky130_fd_sc_hd__decap_3
XFILLER_83_577 VGND VGND VPWR VPWR sky130_fd_sc_hd__fill_2
XFILLER_24_622 VGND VGND VPWR VPWR sky130_fd_sc_hd__decap_3
XFILLER_70_238 VGND VGND VPWR VPWR sky130_fd_sc_hd__decap_3
XFILLER_11_305 VGND VGND VPWR VPWR sky130_fd_sc_hd__decap_3
XFILLER_23_132 VGND VGND VPWR VPWR sky130_fd_sc_hd__decap_3
XFILLER_23_165 VGND VGND VPWR VPWR sky130_fd_sc_hd__decap_3
Xplace290 _3889_/A2 VGND VGND VPWR VPWR _3913_/A2 sky130_fd_sc_hd__buf_2
XFILLER_23_187 VGND VGND VPWR VPWR sky130_fd_sc_hd__fill_1
X_4989_ _5032_/A _5032_/B VGND VGND VPWR VPWR _4989_/X sky130_fd_sc_hd__or2b_2
XFILLER_11_349 VGND VGND VPWR VPWR sky130_fd_sc_hd__fill_2
X_6728_ _6963_/CLK _6728_/D VGND VGND VPWR VPWR _6728_/Q sky130_fd_sc_hd__dfxtp_2
X_6659_ _6662_/A VGND VGND VPWR VPWR _6659_/Y sky130_fd_sc_hd__inv_2
XFILLER_11_54 VGND VGND VPWR VPWR sky130_fd_sc_hd__fill_2
XFILLER_3_559 VGND VGND VPWR VPWR sky130_fd_sc_hd__fill_1
XFILLER_105_476 VGND VGND VPWR VPWR sky130_fd_sc_hd__decap_3
XFILLER_78_316 VGND VGND VPWR VPWR sky130_fd_sc_hd__decap_3
XFILLER_87_69 VGND VGND VPWR VPWR sky130_fd_sc_hd__decap_3
XFILLER_74_500 VGND VGND VPWR VPWR sky130_fd_sc_hd__fill_2
XFILLER_100_170 VGND VGND VPWR VPWR sky130_fd_sc_hd__fill_2
XFILLER_19_438 VGND VGND VPWR VPWR sky130_fd_sc_hd__fill_1
XFILLER_46_213 VGND VGND VPWR VPWR sky130_fd_sc_hd__decap_3
XFILLER_19_449 VGND VGND VPWR VPWR sky130_fd_sc_hd__fill_2
XFILLER_15_600 VGND VGND VPWR VPWR sky130_fd_sc_hd__decap_3
XFILLER_27_460 VGND VGND VPWR VPWR sky130_fd_sc_hd__fill_2
XFILLER_34_408 VGND VGND VPWR VPWR sky130_fd_sc_hd__decap_3
XFILLER_61_205 VGND VGND VPWR VPWR sky130_fd_sc_hd__decap_3
XFILLER_14_121 VGND VGND VPWR VPWR sky130_fd_sc_hd__decap_3
XFILLER_15_644 VGND VGND VPWR VPWR sky130_fd_sc_hd__decap_3
XFILLER_27_482 VGND VGND VPWR VPWR sky130_fd_sc_hd__fill_1
XTAP_TAPCELL_ROW_60_929 VGND VPWR sky130_fd_sc_hd__tapvpwrvgnd_1
XFILLER_14_187 VGND VGND VPWR VPWR sky130_fd_sc_hd__decap_3
XFILLER_30_625 VGND VGND VPWR VPWR sky130_fd_sc_hd__decap_3
XFILLER_42_474 VGND VGND VPWR VPWR sky130_fd_sc_hd__fill_2
XFILLER_52_94 VGND VGND VPWR VPWR sky130_fd_sc_hd__decap_3
XFILLER_10_371 VGND VGND VPWR VPWR sky130_fd_sc_hd__decap_3
XTAP_TAPCELL_ROW_12_377 VGND VPWR sky130_fd_sc_hd__tapvpwrvgnd_1
XTAP_TAPCELL_ROW_40_697 VGND VPWR sky130_fd_sc_hd__tapvpwrvgnd_1
XFILLER_108_281 VGND VGND VPWR VPWR sky130_fd_sc_hd__decap_3
XFILLER_6_397 VGND VGND VPWR VPWR sky130_fd_sc_hd__decap_3
XTAP_TAPCELL_ROW_75_1095 VGND VPWR sky130_fd_sc_hd__tapvpwrvgnd_1
XFILLER_97_625 VGND VGND VPWR VPWR sky130_fd_sc_hd__decap_3
XFILLER_97_603 VGND VGND VPWR VPWR sky130_fd_sc_hd__decap_3
XFILLER_2_581 VGND VGND VPWR VPWR sky130_fd_sc_hd__decap_3
XFILLER_2_592 VGND VGND VPWR VPWR sky130_fd_sc_hd__decap_3
XFILLER_96_135 VGND VGND VPWR VPWR sky130_fd_sc_hd__decap_3
XFILLER_77_80 VGND VGND VPWR VPWR sky130_fd_sc_hd__fill_2
XFILLER_96_179 VGND VGND VPWR VPWR sky130_fd_sc_hd__decap_3
XFILLER_37_202 VGND VGND VPWR VPWR sky130_fd_sc_hd__fill_2
XFILLER_77_393 VGND VGND VPWR VPWR sky130_fd_sc_hd__fill_2
XFILLER_37_246 VGND VGND VPWR VPWR sky130_fd_sc_hd__fill_1
XFILLER_65_555 VGND VGND VPWR VPWR sky130_fd_sc_hd__decap_3
XFILLER_92_341 VGND VGND VPWR VPWR sky130_fd_sc_hd__decap_3
XFILLER_52_216 VGND VGND VPWR VPWR sky130_fd_sc_hd__decap_3
XFILLER_80_514 VGND VGND VPWR VPWR sky130_fd_sc_hd__decap_3
XFILLER_92_374 VGND VGND VPWR VPWR sky130_fd_sc_hd__decap_3
XTAP_TAPCELL_ROW_48_786 VGND VPWR sky130_fd_sc_hd__tapvpwrvgnd_1
XFILLER_45_290 VGND VGND VPWR VPWR sky130_fd_sc_hd__decap_3
XFILLER_52_238 VGND VGND VPWR VPWR sky130_fd_sc_hd__decap_3
XFILLER_80_536 VGND VGND VPWR VPWR sky130_fd_sc_hd__decap_3
XFILLER_93_90 VGND VGND VPWR VPWR sky130_fd_sc_hd__decap_3
X_4912_ _4912_/A _4912_/B VGND VGND VPWR VPWR _6997_/D sky130_fd_sc_hd__nor2_2
XFILLER_21_614 VGND VGND VPWR VPWR sky130_fd_sc_hd__fill_2
XFILLER_21_647 VGND VGND VPWR VPWR sky130_fd_sc_hd__fill_1
XFILLER_33_485 VGND VGND VPWR VPWR sky130_fd_sc_hd__decap_3
XFILLER_60_271 VGND VGND VPWR VPWR sky130_fd_sc_hd__decap_3
X_4843_ _4111_/B _4842_/X _4633_/A VGND VGND VPWR VPWR _4843_/Y sky130_fd_sc_hd__a21oi_2
X_4774_ _7004_/Q _4801_/A VGND VGND VPWR VPWR _4775_/B sky130_fd_sc_hd__nor2_2
XFILLER_20_168 VGND VGND VPWR VPWR sky130_fd_sc_hd__decap_3
X_6513_ _6614_/A VGND VGND VPWR VPWR _6513_/Y sky130_fd_sc_hd__inv_2
X_3725_ _3735_/A _3741_/B _3733_/C VGND VGND VPWR VPWR _3725_/X sky130_fd_sc_hd__and3_2
Xclkbuf_leaf_9_clk clkbuf_leaf_9_clk/A VGND VGND VPWR VPWR _6976_/CLK sky130_fd_sc_hd__clkbuf_16
X_6444_ _6609_/A VGND VGND VPWR VPWR _6444_/Y sky130_fd_sc_hd__inv_2
X_3656_ _3991_/B _3665_/B VGND VGND VPWR VPWR _3656_/Y sky130_fd_sc_hd__nor2_2
X_6375_ _6603_/A VGND VGND VPWR VPWR _6375_/Y sky130_fd_sc_hd__inv_2
X_3587_ _3599_/A _3600_/A VGND VGND VPWR VPWR _4292_/B sky130_fd_sc_hd__or2_4
XFILLER_102_413 VGND VGND VPWR VPWR sky130_fd_sc_hd__decap_3
XFILLER_102_424 VGND VGND VPWR VPWR sky130_fd_sc_hd__decap_3
XFILLER_87_113 VGND VGND VPWR VPWR sky130_fd_sc_hd__decap_3
XFILLER_102_457 VGND VGND VPWR VPWR sky130_fd_sc_hd__decap_3
XFILLER_75_319 VGND VGND VPWR VPWR sky130_fd_sc_hd__decap_3
XFILLER_87_146 VGND VGND VPWR VPWR sky130_fd_sc_hd__decap_3
X_4208_ _4886_/A _4208_/B VGND VGND VPWR VPWR _4903_/A sky130_fd_sc_hd__nor2_2
XFILLER_28_213 VGND VGND VPWR VPWR sky130_fd_sc_hd__decap_3
XFILLER_68_371 VGND VGND VPWR VPWR sky130_fd_sc_hd__decap_3
X_5188_ _5188_/A _5207_/B VGND VGND VPWR VPWR _7234_/D sky130_fd_sc_hd__and2_2
XFILLER_56_533 VGND VGND VPWR VPWR sky130_fd_sc_hd__decap_3
XFILLER_83_330 VGND VGND VPWR VPWR sky130_fd_sc_hd__decap_3
XFILLER_95_190 VGND VGND VPWR VPWR sky130_fd_sc_hd__decap_3
X_4139_ _4207_/A _4642_/B VGND VGND VPWR VPWR _4886_/A sky130_fd_sc_hd__nor2_2
XFILLER_16_408 VGND VGND VPWR VPWR sky130_fd_sc_hd__decap_3
XFILLER_28_279 VGND VGND VPWR VPWR sky130_fd_sc_hd__decap_3
XFILLER_71_503 VGND VGND VPWR VPWR sky130_fd_sc_hd__fill_1
XFILLER_83_352 VGND VGND VPWR VPWR sky130_fd_sc_hd__decap_3
XFILLER_83_385 VGND VGND VPWR VPWR sky130_fd_sc_hd__decap_3
XFILLER_43_238 VGND VGND VPWR VPWR sky130_fd_sc_hd__decap_3
XFILLER_73_49 VGND VGND VPWR VPWR sky130_fd_sc_hd__decap_3
XFILLER_83_396 VGND VGND VPWR VPWR sky130_fd_sc_hd__fill_1
XFILLER_11_113 VGND VGND VPWR VPWR sky130_fd_sc_hd__decap_3
XFILLER_12_625 VGND VGND VPWR VPWR sky130_fd_sc_hd__decap_3
XFILLER_24_474 VGND VGND VPWR VPWR sky130_fd_sc_hd__fill_2
XFILLER_11_135 VGND VGND VPWR VPWR sky130_fd_sc_hd__decap_3
XFILLER_51_293 VGND VGND VPWR VPWR sky130_fd_sc_hd__decap_3
XFILLER_8_607 VGND VGND VPWR VPWR sky130_fd_sc_hd__decap_3
XFILLER_22_97 VGND VGND VPWR VPWR sky130_fd_sc_hd__decap_3
XFILLER_3_378 VGND VGND VPWR VPWR sky130_fd_sc_hd__decap_3
XFILLER_93_105 VGND VGND VPWR VPWR sky130_fd_sc_hd__decap_3
XFILLER_93_116 VGND VGND VPWR VPWR sky130_fd_sc_hd__decap_3
XFILLER_94_639 VGND VGND VPWR VPWR sky130_fd_sc_hd__decap_3
XFILLER_47_83 VGND VGND VPWR VPWR sky130_fd_sc_hd__decap_3
XFILLER_19_257 VGND VGND VPWR VPWR sky130_fd_sc_hd__fill_1
XFILLER_19_268 VGND VGND VPWR VPWR sky130_fd_sc_hd__decap_3
XFILLER_34_216 VGND VGND VPWR VPWR sky130_fd_sc_hd__fill_2
XFILLER_74_352 VGND VGND VPWR VPWR sky130_fd_sc_hd__decap_3
XTAP_TAPCELL_ROW_17_425 VGND VPWR sky130_fd_sc_hd__tapvpwrvgnd_1
XFILLER_15_430 VGND VGND VPWR VPWR sky130_fd_sc_hd__decap_3
XFILLER_15_452 VGND VGND VPWR VPWR sky130_fd_sc_hd__decap_3
XFILLER_63_60 VGND VGND VPWR VPWR sky130_fd_sc_hd__fill_1
XTAP_TAPCELL_ROW_45_756 VGND VPWR sky130_fd_sc_hd__tapvpwrvgnd_1
Xclkbuf_3_4__f_clk clkbuf_0_clk/X VGND VGND VPWR VPWR clkbuf_leaf_9_clk/A sky130_fd_sc_hd__clkbuf_16
XFILLER_30_477 VGND VGND VPWR VPWR sky130_fd_sc_hd__decap_3
XFILLER_8_88 VGND VGND VPWR VPWR sky130_fd_sc_hd__fill_2
XFILLER_8_99 VGND VGND VPWR VPWR sky130_fd_sc_hd__fill_1
X_3510_ _3330_/Y _3383_/B _3442_/B _3353_/B VGND VGND VPWR VPWR _3510_/X sky130_fd_sc_hd__a2bb2o_2
XFILLER_10_190 VGND VGND VPWR VPWR sky130_fd_sc_hd__decap_3
Xhold607 _6847_/Q VGND VGND VPWR VPWR _6847_/D sky130_fd_sc_hd__dlygate4sd3_1
Xhold618 _6865_/Q VGND VGND VPWR VPWR _6865_/D sky130_fd_sc_hd__dlygate4sd3_1
XTAP_TAPCELL_ROW_77_1124 VGND VPWR sky130_fd_sc_hd__tapvpwrvgnd_1
XFILLER_6_172 VGND VGND VPWR VPWR sky130_fd_sc_hd__decap_3
Xhold629 _6789_/Q VGND VGND VPWR VPWR _6789_/D sky130_fd_sc_hd__dlygate4sd3_1
X_3441_ _7058_/Q _3558_/B _3429_/X _3440_/X VGND VGND VPWR VPWR _3544_/A sky130_fd_sc_hd__o211ai_2
XFILLER_40_3 VGND VGND VPWR VPWR sky130_fd_sc_hd__decap_3
XFILLER_69_113 VGND VGND VPWR VPWR sky130_fd_sc_hd__decap_3
X_5111_ _3610_/A _3603_/Y _4292_/C _3548_/X VGND VGND VPWR VPWR _5111_/X sky130_fd_sc_hd__a31o_2
XFILLER_97_411 VGND VGND VPWR VPWR sky130_fd_sc_hd__decap_3
XFILLER_85_617 VGND VGND VPWR VPWR sky130_fd_sc_hd__decap_3
XFILLER_97_455 VGND VGND VPWR VPWR sky130_fd_sc_hd__decap_3
XFILLER_38_522 VGND VGND VPWR VPWR sky130_fd_sc_hd__decap_3
XFILLER_69_179 VGND VGND VPWR VPWR sky130_fd_sc_hd__decap_3
XFILLER_97_488 VGND VGND VPWR VPWR sky130_fd_sc_hd__fill_2
XFILLER_38_555 VGND VGND VPWR VPWR sky130_fd_sc_hd__decap_3
XFILLER_77_190 VGND VGND VPWR VPWR sky130_fd_sc_hd__decap_3
XTAP_TAPCELL_ROW_88_1242 VGND VPWR sky130_fd_sc_hd__tapvpwrvgnd_1
XFILLER_25_205 VGND VGND VPWR VPWR sky130_fd_sc_hd__decap_3
XFILLER_53_503 VGND VGND VPWR VPWR sky130_fd_sc_hd__fill_1
XFILLER_65_363 VGND VGND VPWR VPWR sky130_fd_sc_hd__decap_3
XFILLER_80_300 VGND VGND VPWR VPWR sky130_fd_sc_hd__decap_3
XFILLER_53_547 VGND VGND VPWR VPWR sky130_fd_sc_hd__decap_3
XFILLER_80_333 VGND VGND VPWR VPWR sky130_fd_sc_hd__decap_3
XFILLER_92_171 VGND VGND VPWR VPWR sky130_fd_sc_hd__decap_3
XFILLER_92_182 VGND VGND VPWR VPWR sky130_fd_sc_hd__decap_3
X_6993_ _7392_/CLK _6993_/D _6273_/Y VGND VGND VPWR VPWR _6993_/Q sky130_fd_sc_hd__dfrtp_2
XFILLER_18_290 VGND VGND VPWR VPWR sky130_fd_sc_hd__decap_3
XFILLER_80_355 VGND VGND VPWR VPWR sky130_fd_sc_hd__decap_3
XFILLER_21_455 VGND VGND VPWR VPWR sky130_fd_sc_hd__decap_3
XFILLER_33_293 VGND VGND VPWR VPWR sky130_fd_sc_hd__fill_2
X_4826_ _4826_/A _4826_/B VGND VGND VPWR VPWR _7001_/D sky130_fd_sc_hd__nor2_2
X_4757_ _4757_/A _4665_/X VGND VGND VPWR VPWR _4759_/A sky130_fd_sc_hd__or2b_2
XTAP_TAPCELL_ROW_99_1371 VGND VPWR sky130_fd_sc_hd__tapvpwrvgnd_1
X_4688_ _7001_/Q _7002_/Q _4687_/B _5633_/B VGND VGND VPWR VPWR _4688_/X sky130_fd_sc_hd__a31o_2
X_3708_ _6801_/Q _3824_/B1 _3823_/A2 _6711_/Q _3707_/X VGND VGND VPWR VPWR _3708_/X
+ sky130_fd_sc_hd__a221o_2
X_6427_ _6557_/A VGND VGND VPWR VPWR _6427_/Y sky130_fd_sc_hd__inv_2
X_3639_ _3636_/Y _3548_/X _3505_/X _5020_/A _3638_/X VGND VGND VPWR VPWR _3639_/X
+ sky130_fd_sc_hd__o221a_2
X_6358_ _6684_/A VGND VGND VPWR VPWR _6358_/Y sky130_fd_sc_hd__inv_2
XFILLER_68_38 VGND VGND VPWR VPWR sky130_fd_sc_hd__decap_3
XFILLER_102_232 VGND VGND VPWR VPWR sky130_fd_sc_hd__decap_3
X_6289_ _6364_/A VGND VGND VPWR VPWR _6289_/Y sky130_fd_sc_hd__inv_2
XFILLER_29_511 VGND VGND VPWR VPWR sky130_fd_sc_hd__decap_3
XFILLER_88_488 VGND VGND VPWR VPWR sky130_fd_sc_hd__decap_3
XFILLER_88_499 VGND VGND VPWR VPWR sky130_fd_sc_hd__fill_2
XFILLER_29_533 VGND VGND VPWR VPWR sky130_fd_sc_hd__decap_3
XFILLER_56_374 VGND VGND VPWR VPWR sky130_fd_sc_hd__decap_3
XFILLER_84_48 VGND VGND VPWR VPWR sky130_fd_sc_hd__fill_2
XFILLER_90_108 VGND VGND VPWR VPWR sky130_fd_sc_hd__fill_2
XFILLER_16_216 VGND VGND VPWR VPWR sky130_fd_sc_hd__decap_3
XFILLER_29_599 VGND VGND VPWR VPWR sky130_fd_sc_hd__decap_3
XFILLER_44_547 VGND VGND VPWR VPWR sky130_fd_sc_hd__decap_3
XFILLER_71_311 VGND VGND VPWR VPWR sky130_fd_sc_hd__decap_3
XFILLER_83_193 VGND VGND VPWR VPWR sky130_fd_sc_hd__decap_3
XFILLER_17_97 VGND VGND VPWR VPWR sky130_fd_sc_hd__decap_3
XFILLER_31_219 VGND VGND VPWR VPWR sky130_fd_sc_hd__decap_3
XFILLER_71_377 VGND VGND VPWR VPWR sky130_fd_sc_hd__decap_3
XTAP_TAPCELL_ROW_42_715 VGND VPWR sky130_fd_sc_hd__tapvpwrvgnd_1
XFILLER_12_444 VGND VGND VPWR VPWR sky130_fd_sc_hd__decap_3
XFILLER_12_477 VGND VGND VPWR VPWR sky130_fd_sc_hd__decap_3
XFILLER_8_415 VGND VGND VPWR VPWR sky130_fd_sc_hd__decap_3
XTAP_TAPCELL_ROW_22_483 VGND VPWR sky130_fd_sc_hd__tapvpwrvgnd_1
XFILLER_4_610 VGND VGND VPWR VPWR sky130_fd_sc_hd__decap_3
XFILLER_4_643 VGND VGND VPWR VPWR sky130_fd_sc_hd__fill_1
XFILLER_3_164 VGND VGND VPWR VPWR sky130_fd_sc_hd__decap_3
XFILLER_3_175 VGND VGND VPWR VPWR sky130_fd_sc_hd__decap_3
XFILLER_67_606 VGND VGND VPWR VPWR sky130_fd_sc_hd__decap_3
XFILLER_79_455 VGND VGND VPWR VPWR sky130_fd_sc_hd__decap_3
XTAP_TAPCELL_ROW_72_1065 VGND VPWR sky130_fd_sc_hd__tapvpwrvgnd_1
XFILLER_58_71 VGND VGND VPWR VPWR sky130_fd_sc_hd__decap_3
XFILLER_66_105 VGND VGND VPWR VPWR sky130_fd_sc_hd__fill_2
XFILLER_67_628 VGND VGND VPWR VPWR sky130_fd_sc_hd__decap_3
XFILLER_58_93 VGND VGND VPWR VPWR sky130_fd_sc_hd__decap_3
XFILLER_35_503 VGND VGND VPWR VPWR sky130_fd_sc_hd__fill_1
XFILLER_81_108 VGND VGND VPWR VPWR sky130_fd_sc_hd__decap_3
XFILLER_74_171 VGND VGND VPWR VPWR sky130_fd_sc_hd__decap_3
XFILLER_90_642 VGND VGND VPWR VPWR sky130_fd_sc_hd__fill_2
XFILLER_62_344 VGND VGND VPWR VPWR sky130_fd_sc_hd__decap_3
XFILLER_15_260 VGND VGND VPWR VPWR sky130_fd_sc_hd__decap_3
XFILLER_50_517 VGND VGND VPWR VPWR sky130_fd_sc_hd__decap_3
XFILLER_30_230 VGND VGND VPWR VPWR sky130_fd_sc_hd__decap_3
X_5660_ _5660_/A _5660_/B _5660_/C _5660_/D VGND VGND VPWR VPWR _5661_/D sky130_fd_sc_hd__and4_2
XTAP_TAPCELL_ROW_83_1194 VGND VPWR sky130_fd_sc_hd__tapvpwrvgnd_1
XFILLER_88_3 VGND VGND VPWR VPWR sky130_fd_sc_hd__fill_1
X_4611_ _4611_/A VGND VGND VPWR VPWR _4611_/Y sky130_fd_sc_hd__inv_2
XFILLER_30_274 VGND VGND VPWR VPWR sky130_fd_sc_hd__decap_3
XFILLER_30_296 VGND VGND VPWR VPWR sky130_fd_sc_hd__decap_3
X_5591_ _5591_/A _5595_/B VGND VGND VPWR VPWR _7032_/D sky130_fd_sc_hd__or2_2
X_7330_ _7364_/CLK _7330_/D _6610_/Y VGND VGND VPWR VPWR _7330_/Q sky130_fd_sc_hd__dfrtp_2
X_4542_ _4542_/A _4563_/B VGND VGND VPWR VPWR _7309_/D sky130_fd_sc_hd__and2_2
XFILLER_7_492 VGND VGND VPWR VPWR sky130_fd_sc_hd__decap_3
X_7261_ _7357_/CLK _7261_/D _6541_/Y VGND VGND VPWR VPWR _7261_/Q sky130_fd_sc_hd__dfrtp_2
X_3424_ _3398_/Y _3419_/Y _3424_/S VGND VGND VPWR VPWR _3590_/C sky130_fd_sc_hd__mux2_4
X_7192_ _7387_/CLK _7192_/D _6472_/Y VGND VGND VPWR VPWR _7192_/Q sky130_fd_sc_hd__dfrtp_2
X_3355_ _3371_/A _5668_/A _3519_/B VGND VGND VPWR VPWR _3355_/Y sky130_fd_sc_hd__o21ai_2
XFILLER_57_105 VGND VGND VPWR VPWR sky130_fd_sc_hd__decap_3
XFILLER_58_628 VGND VGND VPWR VPWR sky130_fd_sc_hd__decap_3
Xhold1104 _7292_/Q VGND VGND VPWR VPWR _4577_/A sky130_fd_sc_hd__dlygate4sd3_1
Xhold1115 _7130_/Q VGND VGND VPWR VPWR _5407_/A0 sky130_fd_sc_hd__dlygate4sd3_1
XFILLER_85_436 VGND VGND VPWR VPWR sky130_fd_sc_hd__decap_3
XFILLER_85_447 VGND VGND VPWR VPWR sky130_fd_sc_hd__fill_1
Xhold1126 _7309_/Q VGND VGND VPWR VPWR _4542_/A sky130_fd_sc_hd__dlygate4sd3_1
Xhold1137 _7146_/Q VGND VGND VPWR VPWR _5373_/A0 sky130_fd_sc_hd__dlygate4sd3_1
Xhold1148 _7182_/Q VGND VGND VPWR VPWR _5296_/A0 sky130_fd_sc_hd__dlygate4sd3_1
X_5025_ _6989_/Q _5044_/A _6990_/Q VGND VGND VPWR VPWR _5026_/B sky130_fd_sc_hd__a21oi_2
XFILLER_26_514 VGND VGND VPWR VPWR sky130_fd_sc_hd__fill_2
XFILLER_38_341 VGND VGND VPWR VPWR sky130_fd_sc_hd__fill_1
XFILLER_38_363 VGND VGND VPWR VPWR sky130_fd_sc_hd__fill_1
Xhold1159 _7319_/Q VGND VGND VPWR VPWR _4520_/A0 sky130_fd_sc_hd__dlygate4sd3_1
XFILLER_26_525 VGND VGND VPWR VPWR sky130_fd_sc_hd__decap_3
XFILLER_38_385 VGND VGND VPWR VPWR sky130_fd_sc_hd__decap_3
XFILLER_53_311 VGND VGND VPWR VPWR sky130_fd_sc_hd__fill_1
XFILLER_53_322 VGND VGND VPWR VPWR sky130_fd_sc_hd__decap_3
XFILLER_53_333 VGND VGND VPWR VPWR sky130_fd_sc_hd__decap_3
XFILLER_54_29 VGND VGND VPWR VPWR sky130_fd_sc_hd__decap_3
XFILLER_65_193 VGND VGND VPWR VPWR sky130_fd_sc_hd__decap_3
XFILLER_80_130 VGND VGND VPWR VPWR sky130_fd_sc_hd__decap_3
XFILLER_80_141 VGND VGND VPWR VPWR sky130_fd_sc_hd__fill_2
X_6976_ _6976_/CLK _6976_/D VGND VGND VPWR VPWR _6976_/Q sky130_fd_sc_hd__dfxtp_2
XFILLER_13_219 VGND VGND VPWR VPWR sky130_fd_sc_hd__decap_3
XFILLER_41_539 VGND VGND VPWR VPWR sky130_fd_sc_hd__fill_1
XFILLER_53_399 VGND VGND VPWR VPWR sky130_fd_sc_hd__fill_2
XFILLER_80_163 VGND VGND VPWR VPWR sky130_fd_sc_hd__decap_3
XFILLER_21_274 VGND VGND VPWR VPWR sky130_fd_sc_hd__decap_3
XFILLER_21_296 VGND VGND VPWR VPWR sky130_fd_sc_hd__decap_3
X_4809_ _7002_/Q _4826_/A VGND VGND VPWR VPWR _7002_/D sky130_fd_sc_hd__xor2_2
XPHY_EDGE_ROW_17_Right_17 VGND VGND VPWR VPWR sky130_fd_sc_hd__decap_3
XFILLER_1_602 VGND VGND VPWR VPWR sky130_fd_sc_hd__decap_3
Xhold982 _7013_/Q VGND VGND VPWR VPWR _5630_/A sky130_fd_sc_hd__dlygate4sd3_1
Xhold971 _7377_/Q VGND VGND VPWR VPWR hold971/X sky130_fd_sc_hd__dlygate4sd3_1
Xhold960 _7027_/Q VGND VGND VPWR VPWR _5600_/A sky130_fd_sc_hd__dlygate4sd3_1
XFILLER_49_606 VGND VGND VPWR VPWR sky130_fd_sc_hd__decap_3
Xhold993 _7208_/Q VGND VGND VPWR VPWR hold993/X sky130_fd_sc_hd__dlygate4sd3_1
XFILLER_0_167 VGND VGND VPWR VPWR sky130_fd_sc_hd__fill_1
XFILLER_103_585 VGND VGND VPWR VPWR sky130_fd_sc_hd__decap_3
XFILLER_49_617 VGND VGND VPWR VPWR sky130_fd_sc_hd__decap_3
XFILLER_76_425 VGND VGND VPWR VPWR sky130_fd_sc_hd__fill_2
XPHY_EDGE_ROW_26_Right_26 VGND VGND VPWR VPWR sky130_fd_sc_hd__decap_3
XFILLER_76_447 VGND VGND VPWR VPWR sky130_fd_sc_hd__decap_3
XFILLER_95_69 VGND VGND VPWR VPWR sky130_fd_sc_hd__fill_1
XFILLER_28_63 VGND VGND VPWR VPWR sky130_fd_sc_hd__decap_3
XFILLER_91_428 VGND VGND VPWR VPWR sky130_fd_sc_hd__decap_3
XFILLER_17_547 VGND VGND VPWR VPWR sky130_fd_sc_hd__fill_2
XFILLER_28_85 VGND VGND VPWR VPWR sky130_fd_sc_hd__fill_1
XFILLER_29_385 VGND VGND VPWR VPWR sky130_fd_sc_hd__decap_3
XFILLER_17_558 VGND VGND VPWR VPWR sky130_fd_sc_hd__fill_2
XFILLER_56_193 VGND VGND VPWR VPWR sky130_fd_sc_hd__decap_3
XFILLER_72_642 VGND VGND VPWR VPWR sky130_fd_sc_hd__fill_2
XTAP_TAPCELL_ROW_55_862 VGND VPWR sky130_fd_sc_hd__tapvpwrvgnd_1
XTAP_TAPCELL_ROW_27_542 VGND VPWR sky130_fd_sc_hd__tapvpwrvgnd_1
XTAP_TAPCELL_ROW_106_1459 VGND VPWR sky130_fd_sc_hd__tapvpwrvgnd_1
XTAP_TAPCELL_ROW_106_1448 VGND VPWR sky130_fd_sc_hd__tapvpwrvgnd_1
XFILLER_32_528 VGND VGND VPWR VPWR sky130_fd_sc_hd__fill_1
XFILLER_44_399 VGND VGND VPWR VPWR sky130_fd_sc_hd__decap_3
XFILLER_71_152 VGND VGND VPWR VPWR sky130_fd_sc_hd__decap_3
XFILLER_12_230 VGND VGND VPWR VPWR sky130_fd_sc_hd__decap_3
XFILLER_40_572 VGND VGND VPWR VPWR sky130_fd_sc_hd__fill_2
XPHY_EDGE_ROW_35_Right_35 VGND VGND VPWR VPWR sky130_fd_sc_hd__decap_3
XFILLER_8_245 VGND VGND VPWR VPWR sky130_fd_sc_hd__decap_3
XFILLER_8_256 VGND VGND VPWR VPWR sky130_fd_sc_hd__decap_3
XFILLER_8_278 VGND VGND VPWR VPWR sky130_fd_sc_hd__decap_3
XFILLER_5_12 VGND VGND VPWR VPWR sky130_fd_sc_hd__decap_3
Xoutput509 _7412_/X VGND VGND VPWR VPWR instruction_out[30] sky130_fd_sc_hd__clkdlybuf4s25_1
XFILLER_79_230 VGND VGND VPWR VPWR sky130_fd_sc_hd__fill_1
XFILLER_79_241 VGND VGND VPWR VPWR sky130_fd_sc_hd__decap_3
XPHY_EDGE_ROW_44_Right_44 VGND VGND VPWR VPWR sky130_fd_sc_hd__decap_3
XFILLER_39_116 VGND VGND VPWR VPWR sky130_fd_sc_hd__decap_3
XFILLER_67_414 VGND VGND VPWR VPWR sky130_fd_sc_hd__decap_3
XFILLER_67_425 VGND VGND VPWR VPWR sky130_fd_sc_hd__decap_3
XFILLER_39_149 VGND VGND VPWR VPWR sky130_fd_sc_hd__decap_3
XFILLER_94_222 VGND VGND VPWR VPWR sky130_fd_sc_hd__fill_2
XFILLER_94_244 VGND VGND VPWR VPWR sky130_fd_sc_hd__decap_3
XPHY_EDGE_ROW_19_Left_128 VGND VGND VPWR VPWR sky130_fd_sc_hd__decap_3
XFILLER_63_620 VGND VGND VPWR VPWR sky130_fd_sc_hd__decap_3
XFILLER_94_299 VGND VGND VPWR VPWR sky130_fd_sc_hd__decap_3
XTAP_TAPCELL_ROW_85_1212 VGND VPWR sky130_fd_sc_hd__tapvpwrvgnd_1
XFILLER_62_141 VGND VGND VPWR VPWR sky130_fd_sc_hd__decap_3
X_6830_ clkload6/A _6830_/D VGND VGND VPWR VPWR _6830_/Q sky130_fd_sc_hd__dfxtp_2
XFILLER_35_388 VGND VGND VPWR VPWR sky130_fd_sc_hd__decap_3
X_6761_ clkload5/A _6761_/D VGND VGND VPWR VPWR _6761_/Q sky130_fd_sc_hd__dfxtp_2
XFILLER_16_580 VGND VGND VPWR VPWR sky130_fd_sc_hd__decap_3
X_5712_ _7362_/Q hold918/X _5721_/S VGND VGND VPWR VPWR _6706_/D sky130_fd_sc_hd__mux2_2
X_3973_ _7354_/Q _4515_/A0 _3975_/S VGND VGND VPWR VPWR _7354_/D sky130_fd_sc_hd__mux2_2
XPHY_EDGE_ROW_53_Right_53 VGND VGND VPWR VPWR sky130_fd_sc_hd__decap_3
X_6692_ clkload4/A _6692_/D VGND VGND VPWR VPWR _6692_/Q sky130_fd_sc_hd__dfxtp_2
X_5643_ _5643_/A VGND VGND VPWR VPWR _5643_/X sky130_fd_sc_hd__buf_1
XPHY_EDGE_ROW_28_Left_137 VGND VGND VPWR VPWR sky130_fd_sc_hd__decap_3
X_5574_ hold944/X _5647_/A _4983_/X VGND VGND VPWR VPWR _7043_/D sky130_fd_sc_hd__a21o_2
X_7313_ _7355_/CLK _7313_/D _6593_/Y VGND VGND VPWR VPWR _7313_/Q sky130_fd_sc_hd__dfrtp_2
XTAP_TAPCELL_ROW_96_1341 VGND VPWR sky130_fd_sc_hd__tapvpwrvgnd_1
X_7244_ _7372_/CLK _7244_/D _6524_/Y VGND VGND VPWR VPWR _7244_/Q sky130_fd_sc_hd__dfrtp_2
X_4456_ _4456_/A _4054_/A VGND VGND VPWR VPWR _4456_/X sky130_fd_sc_hd__or2b_2
XPHY_EDGE_ROW_62_Right_62 VGND VGND VPWR VPWR sky130_fd_sc_hd__decap_3
X_7175_ _7405_/CLK _7175_/D _6455_/Y VGND VGND VPWR VPWR _7175_/Q sky130_fd_sc_hd__dfrtp_2
X_4387_ _7241_/Q _4430_/A2 _4459_/C1 _7177_/Q _4386_/X VGND VGND VPWR VPWR _4387_/X
+ sky130_fd_sc_hd__a221o_2
X_3407_ _3421_/B _3421_/C _3417_/C VGND VGND VPWR VPWR _3407_/X sky130_fd_sc_hd__and3_2
XFILLER_58_403 VGND VGND VPWR VPWR sky130_fd_sc_hd__fill_2
XFILLER_58_414 VGND VGND VPWR VPWR sky130_fd_sc_hd__decap_3
XFILLER_100_533 VGND VGND VPWR VPWR sky130_fd_sc_hd__decap_3
XFILLER_105_35 VGND VGND VPWR VPWR sky130_fd_sc_hd__decap_3
XFILLER_105_57 VGND VGND VPWR VPWR sky130_fd_sc_hd__fill_1
XPHY_EDGE_ROW_37_Left_146 VGND VGND VPWR VPWR sky130_fd_sc_hd__decap_3
XFILLER_100_577 VGND VGND VPWR VPWR sky130_fd_sc_hd__decap_3
XFILLER_73_417 VGND VGND VPWR VPWR sky130_fd_sc_hd__decap_3
XFILLER_85_277 VGND VGND VPWR VPWR sky130_fd_sc_hd__decap_3
XFILLER_26_300 VGND VGND VPWR VPWR sky130_fd_sc_hd__fill_1
XFILLER_45_119 VGND VGND VPWR VPWR sky130_fd_sc_hd__decap_3
XFILLER_54_620 VGND VGND VPWR VPWR sky130_fd_sc_hd__decap_3
XFILLER_66_480 VGND VGND VPWR VPWR sky130_fd_sc_hd__fill_1
X_5008_ _4680_/A _5015_/B _5647_/A VGND VGND VPWR VPWR _5009_/B sky130_fd_sc_hd__a21o_2
XFILLER_53_141 VGND VGND VPWR VPWR sky130_fd_sc_hd__decap_3
XFILLER_14_517 VGND VGND VPWR VPWR sky130_fd_sc_hd__decap_3
XFILLER_14_528 VGND VGND VPWR VPWR sky130_fd_sc_hd__decap_3
XPHY_EDGE_ROW_71_Right_71 VGND VGND VPWR VPWR sky130_fd_sc_hd__decap_3
XFILLER_53_196 VGND VGND VPWR VPWR sky130_fd_sc_hd__fill_1
XFILLER_81_38 VGND VGND VPWR VPWR sky130_fd_sc_hd__fill_1
XFILLER_81_494 VGND VGND VPWR VPWR sky130_fd_sc_hd__fill_1
X_6959_ _6965_/CLK _6959_/D VGND VGND VPWR VPWR _6959_/Q sky130_fd_sc_hd__dfxtp_2
XTAP_TAPCELL_ROW_52_832 VGND VPWR sky130_fd_sc_hd__tapvpwrvgnd_1
XTAP_TAPCELL_ROW_24_512 VGND VPWR sky130_fd_sc_hd__tapvpwrvgnd_1
XPHY_EDGE_ROW_46_Left_155 VGND VGND VPWR VPWR sky130_fd_sc_hd__decap_3
XFILLER_108_611 VGND VGND VPWR VPWR sky130_fd_sc_hd__decap_3
XFILLER_5_248 VGND VGND VPWR VPWR sky130_fd_sc_hd__decap_3
XPHY_EDGE_ROW_80_Right_80 VGND VGND VPWR VPWR sky130_fd_sc_hd__decap_3
XFILLER_107_165 VGND VGND VPWR VPWR sky130_fd_sc_hd__decap_3
XFILLER_1_432 VGND VGND VPWR VPWR sky130_fd_sc_hd__fill_1
Xhold790 _6737_/Q VGND VGND VPWR VPWR _6737_/D sky130_fd_sc_hd__dlygate4sd3_1
XFILLER_49_403 VGND VGND VPWR VPWR sky130_fd_sc_hd__decap_3
XFILLER_76_200 VGND VGND VPWR VPWR sky130_fd_sc_hd__decap_3
XFILLER_89_583 VGND VGND VPWR VPWR sky130_fd_sc_hd__decap_3
XPHY_EDGE_ROW_55_Left_164 VGND VGND VPWR VPWR sky130_fd_sc_hd__decap_3
XFILLER_103_393 VGND VGND VPWR VPWR sky130_fd_sc_hd__decap_3
XFILLER_39_84 VGND VGND VPWR VPWR sky130_fd_sc_hd__fill_2
XFILLER_49_458 VGND VGND VPWR VPWR sky130_fd_sc_hd__decap_3
XFILLER_76_244 VGND VGND VPWR VPWR sky130_fd_sc_hd__fill_2
XFILLER_36_119 VGND VGND VPWR VPWR sky130_fd_sc_hd__decap_3
XFILLER_45_620 VGND VGND VPWR VPWR sky130_fd_sc_hd__decap_3
XFILLER_76_299 VGND VGND VPWR VPWR sky130_fd_sc_hd__decap_3
XFILLER_91_203 VGND VGND VPWR VPWR sky130_fd_sc_hd__decap_3
XFILLER_91_225 VGND VGND VPWR VPWR sky130_fd_sc_hd__decap_3
XTAP_TAPCELL_ROW_4_281 VGND VPWR sky130_fd_sc_hd__tapvpwrvgnd_1
XFILLER_29_193 VGND VGND VPWR VPWR sky130_fd_sc_hd__decap_3
XFILLER_44_141 VGND VGND VPWR VPWR sky130_fd_sc_hd__decap_3
XFILLER_57_491 VGND VGND VPWR VPWR sky130_fd_sc_hd__decap_3
XFILLER_91_258 VGND VGND VPWR VPWR sky130_fd_sc_hd__fill_1
XFILLER_44_174 VGND VGND VPWR VPWR sky130_fd_sc_hd__decap_3
XFILLER_55_83 VGND VGND VPWR VPWR sky130_fd_sc_hd__decap_3
XFILLER_60_612 VGND VGND VPWR VPWR sky130_fd_sc_hd__decap_3
XFILLER_72_461 VGND VGND VPWR VPWR sky130_fd_sc_hd__decap_3
XFILLER_72_483 VGND VGND VPWR VPWR sky130_fd_sc_hd__fill_1
XFILLER_17_399 VGND VGND VPWR VPWR sky130_fd_sc_hd__decap_3
XFILLER_60_645 VGND VGND VPWR VPWR sky130_fd_sc_hd__decap_3
XFILLER_72_494 VGND VGND VPWR VPWR sky130_fd_sc_hd__decap_3
XPHY_EDGE_ROW_64_Left_173 VGND VGND VPWR VPWR sky130_fd_sc_hd__decap_3
XFILLER_13_561 VGND VGND VPWR VPWR sky130_fd_sc_hd__decap_3
XTAP_TAPCELL_ROW_80_1153 VGND VPWR sky130_fd_sc_hd__tapvpwrvgnd_1
XFILLER_13_594 VGND VGND VPWR VPWR sky130_fd_sc_hd__decap_3
XFILLER_71_60 VGND VGND VPWR VPWR sky130_fd_sc_hd__decap_3
XFILLER_9_576 VGND VGND VPWR VPWR sky130_fd_sc_hd__decap_3
X_5290_ _5290_/A0 _5156_/X _5292_/S VGND VGND VPWR VPWR _7184_/D sky130_fd_sc_hd__mux2_2
X_4310_ _7352_/Q _4337_/B _4352_/B1 _7160_/Q VGND VGND VPWR VPWR _4311_/C sky130_fd_sc_hd__a22o_2
X_4241_ _5018_/B _4241_/B VGND VGND VPWR VPWR _5032_/A sky130_fd_sc_hd__or2_2
XPHY_EDGE_ROW_73_Left_182 VGND VGND VPWR VPWR sky130_fd_sc_hd__decap_3
XTAP_TAPCELL_ROW_91_1282 VGND VPWR sky130_fd_sc_hd__tapvpwrvgnd_1
XFILLER_67_211 VGND VGND VPWR VPWR sky130_fd_sc_hd__decap_3
XFILLER_67_233 VGND VGND VPWR VPWR sky130_fd_sc_hd__decap_3
X_4172_ _4938_/B _4379_/B VGND VGND VPWR VPWR _4936_/A sky130_fd_sc_hd__nor2_2
XFILLER_67_266 VGND VGND VPWR VPWR sky130_fd_sc_hd__decap_3
XFILLER_95_564 VGND VGND VPWR VPWR sky130_fd_sc_hd__fill_1
XFILLER_36_620 VGND VGND VPWR VPWR sky130_fd_sc_hd__decap_3
XFILLER_48_480 VGND VGND VPWR VPWR sky130_fd_sc_hd__decap_3
XFILLER_35_130 VGND VGND VPWR VPWR sky130_fd_sc_hd__decap_3
XFILLER_82_236 VGND VGND VPWR VPWR sky130_fd_sc_hd__decap_3
XFILLER_23_303 VGND VGND VPWR VPWR sky130_fd_sc_hd__fill_2
XFILLER_51_623 VGND VGND VPWR VPWR sky130_fd_sc_hd__decap_3
XPHY_EDGE_ROW_82_Left_191 VGND VGND VPWR VPWR sky130_fd_sc_hd__decap_3
XFILLER_35_185 VGND VGND VPWR VPWR sky130_fd_sc_hd__decap_3
XFILLER_35_196 VGND VGND VPWR VPWR sky130_fd_sc_hd__decap_3
XFILLER_50_133 VGND VGND VPWR VPWR sky130_fd_sc_hd__decap_3
Xplace450 _6982_/Q VGND VGND VPWR VPWR _3561_/A sky130_fd_sc_hd__buf_2
X_6813_ _6974_/CLK _6813_/D VGND VGND VPWR VPWR _6813_/Q sky130_fd_sc_hd__dfxtp_2
XFILLER_50_144 VGND VGND VPWR VPWR sky130_fd_sc_hd__decap_3
X_6744_ clkload7/A _6744_/D VGND VGND VPWR VPWR _6744_/Q sky130_fd_sc_hd__dfxtp_2
X_3956_ _7362_/Q _3956_/A1 _3956_/S VGND VGND VPWR VPWR _7362_/D sky130_fd_sc_hd__mux2_2
XFILLER_50_188 VGND VGND VPWR VPWR sky130_fd_sc_hd__decap_3
X_6675_ _6677_/A VGND VGND VPWR VPWR _6675_/Y sky130_fd_sc_hd__inv_2
X_5626_ _5626_/A _5634_/B VGND VGND VPWR VPWR _7015_/D sky130_fd_sc_hd__and2_2
X_3887_ _6694_/Q _3887_/A2 _3887_/B1 _6872_/Q _3886_/X VGND VGND VPWR VPWR _3887_/X
+ sky130_fd_sc_hd__a221o_2
XFILLER_105_603 VGND VGND VPWR VPWR sky130_fd_sc_hd__decap_3
XFILLER_105_614 VGND VGND VPWR VPWR sky130_fd_sc_hd__fill_2
XFILLER_2_229 VGND VGND VPWR VPWR sky130_fd_sc_hd__fill_2
X_7227_ _7356_/CLK _7227_/D _6507_/Y VGND VGND VPWR VPWR _7227_/Q sky130_fd_sc_hd__dfrtp_2
X_4439_ _4440_/A _4650_/B VGND VGND VPWR VPWR _4813_/B sky130_fd_sc_hd__or2_2
XFILLER_104_168 VGND VGND VPWR VPWR sky130_fd_sc_hd__decap_3
XFILLER_58_200 VGND VGND VPWR VPWR sky130_fd_sc_hd__decap_3
XFILLER_58_233 VGND VGND VPWR VPWR sky130_fd_sc_hd__decap_3
XFILLER_76_38 VGND VGND VPWR VPWR sky130_fd_sc_hd__fill_2
XFILLER_86_531 VGND VGND VPWR VPWR sky130_fd_sc_hd__fill_1
XFILLER_86_542 VGND VGND VPWR VPWR sky130_fd_sc_hd__decap_3
X_7158_ _7350_/CLK _7158_/D _6438_/Y VGND VGND VPWR VPWR _7158_/Q sky130_fd_sc_hd__dfrtp_2
XFILLER_100_352 VGND VGND VPWR VPWR sky130_fd_sc_hd__decap_3
XFILLER_19_609 VGND VGND VPWR VPWR sky130_fd_sc_hd__decap_3
XFILLER_58_244 VGND VGND VPWR VPWR sky130_fd_sc_hd__decap_3
X_7089_ _7348_/CLK _7089_/D _6369_/Y VGND VGND VPWR VPWR _7089_/Q sky130_fd_sc_hd__dfstp_2
XFILLER_18_108 VGND VGND VPWR VPWR sky130_fd_sc_hd__decap_3
XFILLER_27_620 VGND VGND VPWR VPWR sky130_fd_sc_hd__decap_3
XFILLER_73_225 VGND VGND VPWR VPWR sky130_fd_sc_hd__fill_2
XTAP_TAPCELL_ROW_1_251 VGND VPWR sky130_fd_sc_hd__tapvpwrvgnd_1
XFILLER_26_141 VGND VGND VPWR VPWR sky130_fd_sc_hd__decap_3
XFILLER_26_174 VGND VGND VPWR VPWR sky130_fd_sc_hd__decap_3
XFILLER_42_645 VGND VGND VPWR VPWR sky130_fd_sc_hd__decap_3
XTAP_TAPCELL_ROW_103_1418 VGND VPWR sky130_fd_sc_hd__tapvpwrvgnd_1
XFILLER_25_75 VGND VGND VPWR VPWR sky130_fd_sc_hd__decap_3
XFILLER_41_155 VGND VGND VPWR VPWR sky130_fd_sc_hd__decap_3
XFILLER_10_586 VGND VGND VPWR VPWR sky130_fd_sc_hd__fill_2
XFILLER_108_452 VGND VGND VPWR VPWR sky130_fd_sc_hd__decap_3
XFILLER_6_557 VGND VGND VPWR VPWR sky130_fd_sc_hd__decap_3
XFILLER_108_485 VGND VGND VPWR VPWR sky130_fd_sc_hd__decap_3
XTAP_TAPCELL_ROW_9_340 VGND VPWR sky130_fd_sc_hd__tapvpwrvgnd_1
XFILLER_1_240 VGND VGND VPWR VPWR sky130_fd_sc_hd__decap_3
XFILLER_96_317 VGND VGND VPWR VPWR sky130_fd_sc_hd__fill_1
XFILLER_89_391 VGND VGND VPWR VPWR sky130_fd_sc_hd__fill_1
XFILLER_96_339 VGND VGND VPWR VPWR sky130_fd_sc_hd__decap_3
XFILLER_37_417 VGND VGND VPWR VPWR sky130_fd_sc_hd__decap_3
XFILLER_49_299 VGND VGND VPWR VPWR sky130_fd_sc_hd__fill_1
XFILLER_64_214 VGND VGND VPWR VPWR sky130_fd_sc_hd__decap_3
XTAP_TAPCELL_ROW_69_1026 VGND VPWR sky130_fd_sc_hd__tapvpwrvgnd_1
XFILLER_18_631 VGND VGND VPWR VPWR sky130_fd_sc_hd__decap_3
XFILLER_92_556 VGND VGND VPWR VPWR sky130_fd_sc_hd__decap_3
XFILLER_33_601 VGND VGND VPWR VPWR sky130_fd_sc_hd__decap_3
XFILLER_92_589 VGND VGND VPWR VPWR sky130_fd_sc_hd__decap_3
XFILLER_33_623 VGND VGND VPWR VPWR sky130_fd_sc_hd__decap_3
XFILLER_32_144 VGND VGND VPWR VPWR sky130_fd_sc_hd__fill_1
XFILLER_32_155 VGND VGND VPWR VPWR sky130_fd_sc_hd__decap_3
X_4790_ _4781_/X _4782_/Y _4787_/Y _4948_/A _4789_/X VGND VGND VPWR VPWR _5664_/A
+ sky130_fd_sc_hd__o221a_2
X_3810_ _6846_/Q _3888_/A2 _3893_/B1 _6831_/Q _3809_/X VGND VGND VPWR VPWR _3810_/X
+ sky130_fd_sc_hd__a221o_2
X_3741_ _3746_/A _3741_/B _3746_/C VGND VGND VPWR VPWR _3741_/X sky130_fd_sc_hd__and3_4
XFILLER_9_340 VGND VGND VPWR VPWR sky130_fd_sc_hd__fill_2
X_6460_ _6557_/A VGND VGND VPWR VPWR _6460_/Y sky130_fd_sc_hd__inv_2
X_3672_ _3746_/A _3746_/B _3733_/C VGND VGND VPWR VPWR _3672_/X sky130_fd_sc_hd__or3_2
X_6391_ _6557_/A VGND VGND VPWR VPWR _6391_/Y sky130_fd_sc_hd__inv_2
X_5411_ _5411_/A0 _5094_/X _5427_/S VGND VGND VPWR VPWR _7128_/D sky130_fd_sc_hd__mux2_2
XTAP_TAPCELL_ROW_93_1300 VGND VPWR sky130_fd_sc_hd__tapvpwrvgnd_1
X_5342_ _5342_/A0 _5094_/X _5358_/S VGND VGND VPWR VPWR _7160_/D sky130_fd_sc_hd__mux2_2
XFILLER_99_122 VGND VGND VPWR VPWR sky130_fd_sc_hd__decap_3
X_7012_ _7387_/CLK _7012_/D _6292_/Y VGND VGND VPWR VPWR _7012_/Q sky130_fd_sc_hd__dfrtp_2
XFILLER_99_155 VGND VGND VPWR VPWR sky130_fd_sc_hd__decap_3
XFILLER_102_639 VGND VGND VPWR VPWR sky130_fd_sc_hd__decap_3
XFILLER_68_531 VGND VGND VPWR VPWR sky130_fd_sc_hd__fill_1
X_4224_ _4371_/A _4371_/B _4224_/C VGND VGND VPWR VPWR _4372_/A sky130_fd_sc_hd__and3_2
XFILLER_68_575 VGND VGND VPWR VPWR sky130_fd_sc_hd__decap_3
X_4155_ _4151_/X _4154_/X _4425_/A VGND VGND VPWR VPWR _4205_/C sky130_fd_sc_hd__o21ai_2
XFILLER_55_214 VGND VGND VPWR VPWR sky130_fd_sc_hd__decap_3
XFILLER_55_225 VGND VGND VPWR VPWR sky130_fd_sc_hd__decap_3
XFILLER_83_523 VGND VGND VPWR VPWR sky130_fd_sc_hd__decap_3
XFILLER_83_534 VGND VGND VPWR VPWR sky130_fd_sc_hd__decap_3
XFILLER_55_247 VGND VGND VPWR VPWR sky130_fd_sc_hd__decap_3
XFILLER_83_567 VGND VGND VPWR VPWR sky130_fd_sc_hd__fill_1
X_4086_ _7270_/Q _4422_/A2 _3939_/S _7334_/Q _4085_/X VGND VGND VPWR VPWR _4086_/X
+ sky130_fd_sc_hd__a221o_2
XFILLER_24_601 VGND VGND VPWR VPWR sky130_fd_sc_hd__decap_3
XFILLER_36_472 VGND VGND VPWR VPWR sky130_fd_sc_hd__decap_3
XFILLER_70_217 VGND VGND VPWR VPWR sky130_fd_sc_hd__decap_3
XFILLER_23_111 VGND VGND VPWR VPWR sky130_fd_sc_hd__fill_1
XFILLER_24_634 VGND VGND VPWR VPWR sky130_fd_sc_hd__decap_3
XFILLER_24_645 VGND VGND VPWR VPWR sky130_fd_sc_hd__decap_3
XFILLER_36_483 VGND VGND VPWR VPWR sky130_fd_sc_hd__decap_3
XFILLER_36_494 VGND VGND VPWR VPWR sky130_fd_sc_hd__decap_3
XFILLER_51_431 VGND VGND VPWR VPWR sky130_fd_sc_hd__decap_3
XFILLER_23_144 VGND VGND VPWR VPWR sky130_fd_sc_hd__decap_3
XFILLER_51_464 VGND VGND VPWR VPWR sky130_fd_sc_hd__fill_2
Xplace291 _3879_/B1 VGND VGND VPWR VPWR _3889_/A2 sky130_fd_sc_hd__buf_2
Xplace280 _3888_/A2 VGND VGND VPWR VPWR _3912_/A2 sky130_fd_sc_hd__buf_2
XFILLER_11_317 VGND VGND VPWR VPWR sky130_fd_sc_hd__decap_3
X_4988_ _4988_/A _4988_/B VGND VGND VPWR VPWR _5004_/A sky130_fd_sc_hd__nor2_2
X_6727_ clkload6/A _6727_/D VGND VGND VPWR VPWR _6727_/Q sky130_fd_sc_hd__dfxtp_2
X_3939_ _7370_/Q _7338_/Q _3939_/S VGND VGND VPWR VPWR _7370_/D sky130_fd_sc_hd__mux2_2
X_6658_ _6667_/A VGND VGND VPWR VPWR _6658_/Y sky130_fd_sc_hd__inv_2
X_5609_ _5609_/A _5633_/B VGND VGND VPWR VPWR _7023_/D sky130_fd_sc_hd__or2_2
XFILLER_105_411 VGND VGND VPWR VPWR sky130_fd_sc_hd__decap_3
XFILLER_11_66 VGND VGND VPWR VPWR sky130_fd_sc_hd__decap_3
XFILLER_3_505 VGND VGND VPWR VPWR sky130_fd_sc_hd__decap_3
X_6589_ _6589_/A VGND VGND VPWR VPWR _6589_/Y sky130_fd_sc_hd__inv_2
XFILLER_11_88 VGND VGND VPWR VPWR sky130_fd_sc_hd__fill_2
XFILLER_2_6 VGND VGND VPWR VPWR sky130_fd_sc_hd__decap_3
XFILLER_3_538 VGND VGND VPWR VPWR sky130_fd_sc_hd__decap_3
XFILLER_86_350 VGND VGND VPWR VPWR sky130_fd_sc_hd__decap_3
XFILLER_93_309 VGND VGND VPWR VPWR sky130_fd_sc_hd__decap_3
XFILLER_19_417 VGND VGND VPWR VPWR sky130_fd_sc_hd__decap_3
XFILLER_86_361 VGND VGND VPWR VPWR sky130_fd_sc_hd__decap_3
XFILLER_86_372 VGND VGND VPWR VPWR sky130_fd_sc_hd__decap_3
XFILLER_46_225 VGND VGND VPWR VPWR sky130_fd_sc_hd__decap_3
XFILLER_46_247 VGND VGND VPWR VPWR sky130_fd_sc_hd__decap_3
XFILLER_86_394 VGND VGND VPWR VPWR sky130_fd_sc_hd__decap_3
XFILLER_15_612 VGND VGND VPWR VPWR sky130_fd_sc_hd__decap_3
XFILLER_74_589 VGND VGND VPWR VPWR sky130_fd_sc_hd__fill_1
XFILLER_14_100 VGND VGND VPWR VPWR sky130_fd_sc_hd__fill_1
XFILLER_15_623 VGND VGND VPWR VPWR sky130_fd_sc_hd__decap_3
XFILLER_27_494 VGND VGND VPWR VPWR sky130_fd_sc_hd__fill_1
XFILLER_36_85 VGND VGND VPWR VPWR sky130_fd_sc_hd__fill_1
XFILLER_61_228 VGND VGND VPWR VPWR sky130_fd_sc_hd__decap_3
XFILLER_61_239 VGND VGND VPWR VPWR sky130_fd_sc_hd__decap_3
XFILLER_14_133 VGND VGND VPWR VPWR sky130_fd_sc_hd__decap_3
XFILLER_14_144 VGND VGND VPWR VPWR sky130_fd_sc_hd__decap_3
XFILLER_30_604 VGND VGND VPWR VPWR sky130_fd_sc_hd__decap_3
XFILLER_54_291 VGND VGND VPWR VPWR sky130_fd_sc_hd__decap_3
XTAP_TAPCELL_ROW_60_919 VGND VPWR sky130_fd_sc_hd__tapvpwrvgnd_1
XFILLER_30_637 VGND VGND VPWR VPWR sky130_fd_sc_hd__decap_3
XFILLER_10_361 VGND VGND VPWR VPWR sky130_fd_sc_hd__decap_3
XTAP_TAPCELL_ROW_12_378 VGND VPWR sky130_fd_sc_hd__tapvpwrvgnd_1
XTAP_TAPCELL_ROW_12_367 VGND VPWR sky130_fd_sc_hd__tapvpwrvgnd_1
XFILLER_10_383 VGND VGND VPWR VPWR sky130_fd_sc_hd__fill_2
XFILLER_6_321 VGND VGND VPWR VPWR sky130_fd_sc_hd__fill_1
XTAP_TAPCELL_ROW_40_698 VGND VPWR sky130_fd_sc_hd__tapvpwrvgnd_1
XFILLER_108_271 VGND VGND VPWR VPWR sky130_fd_sc_hd__fill_2
XFILLER_6_365 VGND VGND VPWR VPWR sky130_fd_sc_hd__decap_3
XFILLER_2_560 VGND VGND VPWR VPWR sky130_fd_sc_hd__decap_3
XFILLER_97_615 VGND VGND VPWR VPWR sky130_fd_sc_hd__fill_1
XTAP_TAPCELL_ROW_75_1096 VGND VPWR sky130_fd_sc_hd__tapvpwrvgnd_1
XFILLER_97_637 VGND VGND VPWR VPWR sky130_fd_sc_hd__decap_3
XFILLER_96_158 VGND VGND VPWR VPWR sky130_fd_sc_hd__decap_3
XFILLER_77_372 VGND VGND VPWR VPWR sky130_fd_sc_hd__decap_3
XFILLER_37_225 VGND VGND VPWR VPWR sky130_fd_sc_hd__decap_3
XFILLER_18_461 VGND VGND VPWR VPWR sky130_fd_sc_hd__decap_3
XFILLER_80_526 VGND VGND VPWR VPWR sky130_fd_sc_hd__decap_3
XTAP_TAPCELL_ROW_48_787 VGND VPWR sky130_fd_sc_hd__tapvpwrvgnd_1
XFILLER_18_494 VGND VGND VPWR VPWR sky130_fd_sc_hd__decap_3
XFILLER_52_228 VGND VGND VPWR VPWR sky130_fd_sc_hd__fill_2
XFILLER_80_548 VGND VGND VPWR VPWR sky130_fd_sc_hd__fill_2
X_4911_ _6997_/Q _4931_/A VGND VGND VPWR VPWR _4912_/B sky130_fd_sc_hd__nor2_2
XFILLER_20_103 VGND VGND VPWR VPWR sky130_fd_sc_hd__fill_1
XFILLER_21_626 VGND VGND VPWR VPWR sky130_fd_sc_hd__decap_3
XFILLER_33_497 VGND VGND VPWR VPWR sky130_fd_sc_hd__decap_3
XFILLER_60_283 VGND VGND VPWR VPWR sky130_fd_sc_hd__decap_3
X_4842_ _4643_/Y _4841_/Y _4845_/A VGND VGND VPWR VPWR _4842_/X sky130_fd_sc_hd__a21o_2
XFILLER_20_147 VGND VGND VPWR VPWR sky130_fd_sc_hd__decap_3
X_6512_ _6609_/A VGND VGND VPWR VPWR _6512_/Y sky130_fd_sc_hd__inv_2
X_3724_ _6828_/Q _3881_/A2 _3883_/A2 _6818_/Q _3723_/X VGND VGND VPWR VPWR _3724_/X
+ sky130_fd_sc_hd__a221o_2
X_6443_ _6602_/A VGND VGND VPWR VPWR _6443_/Y sky130_fd_sc_hd__inv_2
XFILLER_9_181 VGND VGND VPWR VPWR sky130_fd_sc_hd__decap_3
X_6374_ _6592_/A VGND VGND VPWR VPWR _6374_/Y sky130_fd_sc_hd__inv_2
X_3586_ _3586_/A _3591_/B _3591_/C _3586_/D VGND VGND VPWR VPWR _3586_/Y sky130_fd_sc_hd__nor4_2
XFILLER_0_519 VGND VGND VPWR VPWR sky130_fd_sc_hd__decap_3
X_5325_ _5325_/A0 _4964_/X _5333_/S VGND VGND VPWR VPWR _7168_/D sky130_fd_sc_hd__mux2_2
X_5256_ _5256_/A0 _4932_/X _5276_/S VGND VGND VPWR VPWR _7202_/D sky130_fd_sc_hd__mux2_2
XFILLER_102_469 VGND VGND VPWR VPWR sky130_fd_sc_hd__decap_3
XFILLER_87_158 VGND VGND VPWR VPWR sky130_fd_sc_hd__decap_3
XFILLER_87_169 VGND VGND VPWR VPWR sky130_fd_sc_hd__decap_3
X_4207_ _4207_/A _4642_/B VGND VGND VPWR VPWR _4208_/B sky130_fd_sc_hd__and2_2
XFILLER_68_361 VGND VGND VPWR VPWR sky130_fd_sc_hd__decap_3
XFILLER_68_383 VGND VGND VPWR VPWR sky130_fd_sc_hd__fill_2
XFILLER_28_236 VGND VGND VPWR VPWR sky130_fd_sc_hd__decap_3
XFILLER_68_394 VGND VGND VPWR VPWR sky130_fd_sc_hd__decap_3
X_4138_ _4134_/X _4137_/X _4425_/A VGND VGND VPWR VPWR _4642_/B sky130_fd_sc_hd__o21a_2
XFILLER_43_206 VGND VGND VPWR VPWR sky130_fd_sc_hd__decap_3
XFILLER_56_589 VGND VGND VPWR VPWR sky130_fd_sc_hd__fill_2
XFILLER_83_364 VGND VGND VPWR VPWR sky130_fd_sc_hd__decap_3
X_4069_ _4744_/B _4069_/B VGND VGND VPWR VPWR _4069_/Y sky130_fd_sc_hd__nor2_2
XFILLER_43_228 VGND VGND VPWR VPWR sky130_fd_sc_hd__fill_2
XFILLER_71_559 VGND VGND VPWR VPWR sky130_fd_sc_hd__fill_1
XFILLER_12_604 VGND VGND VPWR VPWR sky130_fd_sc_hd__decap_3
XFILLER_24_453 VGND VGND VPWR VPWR sky130_fd_sc_hd__decap_3
XFILLER_12_637 VGND VGND VPWR VPWR sky130_fd_sc_hd__decap_3
XFILLER_24_486 VGND VGND VPWR VPWR sky130_fd_sc_hd__decap_3
XFILLER_51_261 VGND VGND VPWR VPWR sky130_fd_sc_hd__decap_3
XFILLER_11_147 VGND VGND VPWR VPWR sky130_fd_sc_hd__decap_3
XFILLER_8_619 VGND VGND VPWR VPWR sky130_fd_sc_hd__decap_3
XFILLER_11_169 VGND VGND VPWR VPWR sky130_fd_sc_hd__decap_3
XFILLER_7_107 VGND VGND VPWR VPWR sky130_fd_sc_hd__decap_3
XFILLER_3_313 VGND VGND VPWR VPWR sky130_fd_sc_hd__decap_3
XFILLER_3_346 VGND VGND VPWR VPWR sky130_fd_sc_hd__decap_3
XFILLER_79_604 VGND VGND VPWR VPWR sky130_fd_sc_hd__decap_3
XFILLER_98_69 VGND VGND VPWR VPWR sky130_fd_sc_hd__decap_3
XFILLER_105_296 VGND VGND VPWR VPWR sky130_fd_sc_hd__decap_3
XFILLER_78_114 VGND VGND VPWR VPWR sky130_fd_sc_hd__decap_3
XFILLER_66_309 VGND VGND VPWR VPWR sky130_fd_sc_hd__decap_3
XFILLER_78_147 VGND VGND VPWR VPWR sky130_fd_sc_hd__decap_3
XFILLER_47_501 VGND VGND VPWR VPWR sky130_fd_sc_hd__decap_3
XFILLER_19_236 VGND VGND VPWR VPWR sky130_fd_sc_hd__decap_3
XFILLER_47_51 VGND VGND VPWR VPWR sky130_fd_sc_hd__decap_3
XFILLER_47_556 VGND VGND VPWR VPWR sky130_fd_sc_hd__decap_3
XFILLER_86_191 VGND VGND VPWR VPWR sky130_fd_sc_hd__decap_3
XFILLER_47_567 VGND VGND VPWR VPWR sky130_fd_sc_hd__fill_2
XTAP_TAPCELL_ROW_17_426 VGND VPWR sky130_fd_sc_hd__tapvpwrvgnd_1
XFILLER_15_442 VGND VGND VPWR VPWR sky130_fd_sc_hd__decap_3
XTAP_TAPCELL_ROW_45_757 VGND VPWR sky130_fd_sc_hd__tapvpwrvgnd_1
XFILLER_15_464 VGND VGND VPWR VPWR sky130_fd_sc_hd__fill_1
XFILLER_15_486 VGND VGND VPWR VPWR sky130_fd_sc_hd__decap_3
XFILLER_63_72 VGND VGND VPWR VPWR sky130_fd_sc_hd__decap_3
XFILLER_70_581 VGND VGND VPWR VPWR sky130_fd_sc_hd__decap_3
XFILLER_70_592 VGND VGND VPWR VPWR sky130_fd_sc_hd__decap_3
XFILLER_8_67 VGND VGND VPWR VPWR sky130_fd_sc_hd__decap_3
XFILLER_7_641 VGND VGND VPWR VPWR sky130_fd_sc_hd__decap_3
Xwire550 _3896_/Y VGND VGND VPWR VPWR wire550/X sky130_fd_sc_hd__clkdlybuf4s25_1
XFILLER_6_151 VGND VGND VPWR VPWR sky130_fd_sc_hd__decap_3
Xhold608 _6917_/Q VGND VGND VPWR VPWR _6917_/D sky130_fd_sc_hd__dlygate4sd3_1
Xwire561 _3475_/Y VGND VGND VPWR VPWR _3502_/A sky130_fd_sc_hd__clkbuf_2
XTAP_TAPCELL_ROW_77_1125 VGND VPWR sky130_fd_sc_hd__tapvpwrvgnd_1
XFILLER_6_184 VGND VGND VPWR VPWR sky130_fd_sc_hd__decap_3
Xhold619 _6781_/Q VGND VGND VPWR VPWR _6781_/D sky130_fd_sc_hd__dlygate4sd3_1
X_3440_ _7250_/Q _4260_/A2 _3434_/X _3439_/X VGND VGND VPWR VPWR _3440_/X sky130_fd_sc_hd__a211o_2
X_3371_ _3371_/A _5118_/D _5118_/A _5129_/B VGND VGND VPWR VPWR _3371_/Y sky130_fd_sc_hd__nor4bb_1
XFILLER_33_3 VGND VGND VPWR VPWR sky130_fd_sc_hd__fill_1
X_5110_ _3610_/A _3603_/Y _4292_/C VGND VGND VPWR VPWR _5110_/Y sky130_fd_sc_hd__a21oi_2
XFILLER_97_423 VGND VGND VPWR VPWR sky130_fd_sc_hd__decap_3
XFILLER_85_607 VGND VGND VPWR VPWR sky130_fd_sc_hd__decap_3
X_5041_ _5041_/A0 _5040_/X _5159_/S VGND VGND VPWR VPWR _7259_/D sky130_fd_sc_hd__mux2_2
XFILLER_69_169 VGND VGND VPWR VPWR sky130_fd_sc_hd__fill_1
XFILLER_38_578 VGND VGND VPWR VPWR sky130_fd_sc_hd__fill_1
XFILLER_92_150 VGND VGND VPWR VPWR sky130_fd_sc_hd__decap_3
XTAP_TAPCELL_ROW_88_1243 VGND VPWR sky130_fd_sc_hd__tapvpwrvgnd_1
XFILLER_25_228 VGND VGND VPWR VPWR sky130_fd_sc_hd__decap_3
XFILLER_80_312 VGND VGND VPWR VPWR sky130_fd_sc_hd__decap_3
XFILLER_92_194 VGND VGND VPWR VPWR sky130_fd_sc_hd__fill_2
X_6992_ _7392_/CLK _6992_/D _6272_/Y VGND VGND VPWR VPWR _6992_/Q sky130_fd_sc_hd__dfrtp_2
XFILLER_33_250 VGND VGND VPWR VPWR sky130_fd_sc_hd__decap_3
XFILLER_40_209 VGND VGND VPWR VPWR sky130_fd_sc_hd__decap_3
XFILLER_80_378 VGND VGND VPWR VPWR sky130_fd_sc_hd__decap_3
X_4825_ _7001_/Q _4825_/B VGND VGND VPWR VPWR _4826_/B sky130_fd_sc_hd__nor2_2
XFILLER_21_467 VGND VGND VPWR VPWR sky130_fd_sc_hd__decap_3
XFILLER_21_489 VGND VGND VPWR VPWR sky130_fd_sc_hd__decap_3
XFILLER_107_517 VGND VGND VPWR VPWR sky130_fd_sc_hd__fill_1
X_4687_ _7001_/Q _4687_/B VGND VGND VPWR VPWR _4834_/A sky130_fd_sc_hd__and2_2
X_3707_ _6937_/Q _3862_/A2 _3883_/B1 _6889_/Q VGND VGND VPWR VPWR _3707_/X sky130_fd_sc_hd__a22o_2
XTAP_TAPCELL_ROW_99_1372 VGND VPWR sky130_fd_sc_hd__tapvpwrvgnd_1
XFILLER_108_35 VGND VGND VPWR VPWR sky130_fd_sc_hd__decap_3
X_6426_ _6650_/A VGND VGND VPWR VPWR _6426_/Y sky130_fd_sc_hd__inv_2
X_3638_ _3635_/A _3618_/C _3547_/A VGND VGND VPWR VPWR _3638_/X sky130_fd_sc_hd__a21bo_2
XFILLER_108_57 VGND VGND VPWR VPWR sky130_fd_sc_hd__decap_3
XFILLER_88_401 VGND VGND VPWR VPWR sky130_fd_sc_hd__fill_1
X_6357_ _6364_/A VGND VGND VPWR VPWR _6357_/Y sky130_fd_sc_hd__inv_2
X_3569_ _7285_/Q _5132_/S _3567_/X _3568_/X VGND VGND VPWR VPWR _3569_/X sky130_fd_sc_hd__a211o_2
XFILLER_0_305 VGND VGND VPWR VPWR sky130_fd_sc_hd__decap_3
XFILLER_0_327 VGND VGND VPWR VPWR sky130_fd_sc_hd__decap_3
X_5308_ _5308_/A0 _4822_/X _5310_/S VGND VGND VPWR VPWR _7176_/D sky130_fd_sc_hd__mux2_2
XFILLER_88_445 VGND VGND VPWR VPWR sky130_fd_sc_hd__decap_3
X_6288_ _6397_/A VGND VGND VPWR VPWR _6288_/Y sky130_fd_sc_hd__inv_2
XFILLER_48_309 VGND VGND VPWR VPWR sky130_fd_sc_hd__decap_3
XFILLER_76_629 VGND VGND VPWR VPWR sky130_fd_sc_hd__decap_3
X_5239_ _5239_/A1 _5238_/X _4766_/A VGND VGND VPWR VPWR _7211_/D sky130_fd_sc_hd__a21o_2
XFILLER_102_299 VGND VGND VPWR VPWR sky130_fd_sc_hd__fill_1
XFILLER_29_523 VGND VGND VPWR VPWR sky130_fd_sc_hd__fill_1
XFILLER_68_180 VGND VGND VPWR VPWR sky130_fd_sc_hd__fill_1
XFILLER_75_139 VGND VGND VPWR VPWR sky130_fd_sc_hd__decap_3
XFILLER_44_504 VGND VGND VPWR VPWR sky130_fd_sc_hd__decap_3
XFILLER_56_342 VGND VGND VPWR VPWR sky130_fd_sc_hd__fill_2
XFILLER_56_353 VGND VGND VPWR VPWR sky130_fd_sc_hd__fill_1
XFILLER_16_228 VGND VGND VPWR VPWR sky130_fd_sc_hd__decap_3
XFILLER_56_386 VGND VGND VPWR VPWR sky130_fd_sc_hd__fill_2
XFILLER_83_172 VGND VGND VPWR VPWR sky130_fd_sc_hd__decap_3
XTAP_TAPCELL_ROW_108_1490 VGND VPWR sky130_fd_sc_hd__tapvpwrvgnd_1
XTAP_TAPCELL_ROW_42_716 VGND VPWR sky130_fd_sc_hd__tapvpwrvgnd_1
XFILLER_12_456 VGND VGND VPWR VPWR sky130_fd_sc_hd__decap_3
XTAP_TAPCELL_ROW_22_484 VGND VPWR sky130_fd_sc_hd__tapvpwrvgnd_1
XFILLER_4_622 VGND VGND VPWR VPWR sky130_fd_sc_hd__decap_3
XFILLER_98_209 VGND VGND VPWR VPWR sky130_fd_sc_hd__fill_2
XFILLER_79_467 VGND VGND VPWR VPWR sky130_fd_sc_hd__decap_3
XTAP_TAPCELL_ROW_72_1066 VGND VPWR sky130_fd_sc_hd__tapvpwrvgnd_1
XFILLER_39_309 VGND VGND VPWR VPWR sky130_fd_sc_hd__decap_3
XFILLER_58_83 VGND VGND VPWR VPWR sky130_fd_sc_hd__fill_1
XFILLER_59_191 VGND VGND VPWR VPWR sky130_fd_sc_hd__decap_3
XFILLER_94_448 VGND VGND VPWR VPWR sky130_fd_sc_hd__decap_3
XFILLER_74_150 VGND VGND VPWR VPWR sky130_fd_sc_hd__decap_3
XFILLER_35_515 VGND VGND VPWR VPWR sky130_fd_sc_hd__decap_3
XFILLER_47_386 VGND VGND VPWR VPWR sky130_fd_sc_hd__decap_3
XFILLER_74_183 VGND VGND VPWR VPWR sky130_fd_sc_hd__fill_2
XFILLER_74_194 VGND VGND VPWR VPWR sky130_fd_sc_hd__fill_2
XFILLER_74_93 VGND VGND VPWR VPWR sky130_fd_sc_hd__decap_3
XFILLER_43_570 VGND VGND VPWR VPWR sky130_fd_sc_hd__decap_3
XFILLER_15_272 VGND VGND VPWR VPWR sky130_fd_sc_hd__fill_2
XTAP_TAPCELL_ROW_83_1184 VGND VPWR sky130_fd_sc_hd__tapvpwrvgnd_1
XFILLER_30_253 VGND VGND VPWR VPWR sky130_fd_sc_hd__decap_3
X_4610_ _4745_/A _4762_/B VGND VGND VPWR VPWR _4611_/A sky130_fd_sc_hd__nand2_2
XFILLER_30_286 VGND VGND VPWR VPWR sky130_fd_sc_hd__decap_3
XFILLER_7_482 VGND VGND VPWR VPWR sky130_fd_sc_hd__fill_1
X_7260_ _7280_/CLK _7260_/D _6540_/Y VGND VGND VPWR VPWR _7260_/Q sky130_fd_sc_hd__dfrtp_2
X_7191_ _7387_/CLK _7191_/D _6471_/Y VGND VGND VPWR VPWR _7191_/Q sky130_fd_sc_hd__dfrtp_2
X_3423_ _3423_/A _3442_/B _3423_/C VGND VGND VPWR VPWR _3424_/S sky130_fd_sc_hd__and3_4
X_3354_ _3371_/A _5668_/A _3328_/B _5670_/A VGND VGND VPWR VPWR _3354_/X sky130_fd_sc_hd__a211o_2
XFILLER_97_231 VGND VGND VPWR VPWR sky130_fd_sc_hd__decap_3
XFILLER_85_415 VGND VGND VPWR VPWR sky130_fd_sc_hd__decap_3
Xhold1105 _7341_/Q VGND VGND VPWR VPWR _4476_/A0 sky130_fd_sc_hd__dlygate4sd3_1
XFILLER_38_331 VGND VGND VPWR VPWR sky130_fd_sc_hd__decap_3
XFILLER_66_640 VGND VGND VPWR VPWR sky130_fd_sc_hd__decap_3
Xhold1116 _7179_/Q VGND VGND VPWR VPWR _5302_/A0 sky130_fd_sc_hd__dlygate4sd3_1
Xhold1127 _7237_/Q VGND VGND VPWR VPWR _5182_/A sky130_fd_sc_hd__dlygate4sd3_1
Xhold1138 _7337_/Q VGND VGND VPWR VPWR _4484_/A0 sky130_fd_sc_hd__dlygate4sd3_1
Xhold1149 _7149_/Q VGND VGND VPWR VPWR _5367_/A0 sky130_fd_sc_hd__dlygate4sd3_1
X_5024_ _3864_/S _3832_/X _5015_/X _5023_/Y VGND VGND VPWR VPWR _5024_/X sky130_fd_sc_hd__a211o_2
XFILLER_38_375 VGND VGND VPWR VPWR sky130_fd_sc_hd__decap_3
XFILLER_65_172 VGND VGND VPWR VPWR sky130_fd_sc_hd__decap_3
X_6975_ clkload6/A _6975_/D VGND VGND VPWR VPWR _6975_/Q sky130_fd_sc_hd__dfxtp_2
XFILLER_34_570 VGND VGND VPWR VPWR sky130_fd_sc_hd__decap_3
XFILLER_53_378 VGND VGND VPWR VPWR sky130_fd_sc_hd__decap_3
XFILLER_80_175 VGND VGND VPWR VPWR sky130_fd_sc_hd__decap_3
XFILLER_80_197 VGND VGND VPWR VPWR sky130_fd_sc_hd__decap_3
XFILLER_21_253 VGND VGND VPWR VPWR sky130_fd_sc_hd__decap_3
XFILLER_107_303 VGND VGND VPWR VPWR sky130_fd_sc_hd__decap_3
XFILLER_5_419 VGND VGND VPWR VPWR sky130_fd_sc_hd__decap_3
X_4739_ _4762_/A _4762_/B _4765_/B _4745_/A VGND VGND VPWR VPWR _4739_/Y sky130_fd_sc_hd__a211oi_2
XFILLER_102_6 VGND VGND VPWR VPWR sky130_fd_sc_hd__decap_3
X_6409_ _6638_/A VGND VGND VPWR VPWR _6409_/Y sky130_fd_sc_hd__inv_2
XFILLER_0_102 VGND VGND VPWR VPWR sky130_fd_sc_hd__fill_2
XFILLER_1_614 VGND VGND VPWR VPWR sky130_fd_sc_hd__fill_2
X_7389_ _7398_/CLK _7389_/D _6669_/Y VGND VGND VPWR VPWR _7389_/Q sky130_fd_sc_hd__dfrtp_2
Xhold972 _7375_/Q VGND VGND VPWR VPWR hold972/X sky130_fd_sc_hd__dlygate4sd3_1
Xhold961 _7376_/Q VGND VGND VPWR VPWR hold961/X sky130_fd_sc_hd__dlygate4sd3_1
Xhold950 _7049_/Q VGND VGND VPWR VPWR hold950/X sky130_fd_sc_hd__dlygate4sd3_1
XFILLER_0_113 VGND VGND VPWR VPWR sky130_fd_sc_hd__decap_3
XFILLER_0_135 VGND VGND VPWR VPWR sky130_fd_sc_hd__decap_3
XFILLER_88_220 VGND VGND VPWR VPWR sky130_fd_sc_hd__decap_3
XFILLER_88_242 VGND VGND VPWR VPWR sky130_fd_sc_hd__fill_2
Xhold994 _7214_/Q VGND VGND VPWR VPWR hold994/X sky130_fd_sc_hd__dlygate4sd3_1
Xhold983 _7012_/Q VGND VGND VPWR VPWR _5632_/A sky130_fd_sc_hd__dlygate4sd3_1
XFILLER_103_564 VGND VGND VPWR VPWR sky130_fd_sc_hd__decap_3
XFILLER_49_629 VGND VGND VPWR VPWR sky130_fd_sc_hd__decap_3
XFILLER_76_404 VGND VGND VPWR VPWR sky130_fd_sc_hd__decap_3
XFILLER_88_253 VGND VGND VPWR VPWR sky130_fd_sc_hd__decap_3
XFILLER_29_320 VGND VGND VPWR VPWR sky130_fd_sc_hd__decap_3
XFILLER_76_459 VGND VGND VPWR VPWR sky130_fd_sc_hd__decap_3
XFILLER_17_526 VGND VGND VPWR VPWR sky130_fd_sc_hd__decap_3
XFILLER_29_375 VGND VGND VPWR VPWR sky130_fd_sc_hd__fill_1
XFILLER_84_470 VGND VGND VPWR VPWR sky130_fd_sc_hd__decap_3
XTAP_TAPCELL_ROW_27_543 VGND VPWR sky130_fd_sc_hd__tapvpwrvgnd_1
XTAP_TAPCELL_ROW_106_1449 VGND VPWR sky130_fd_sc_hd__tapvpwrvgnd_1
XFILLER_25_570 VGND VGND VPWR VPWR sky130_fd_sc_hd__fill_1
XFILLER_32_518 VGND VGND VPWR VPWR sky130_fd_sc_hd__fill_1
XFILLER_44_378 VGND VGND VPWR VPWR sky130_fd_sc_hd__decap_3
XFILLER_44_52 VGND VGND VPWR VPWR sky130_fd_sc_hd__decap_3
XFILLER_71_164 VGND VGND VPWR VPWR sky130_fd_sc_hd__decap_3
XFILLER_71_175 VGND VGND VPWR VPWR sky130_fd_sc_hd__decap_3
XTAP_TAPCELL_ROW_55_863 VGND VPWR sky130_fd_sc_hd__tapvpwrvgnd_1
XFILLER_44_85 VGND VGND VPWR VPWR sky130_fd_sc_hd__decap_3
XFILLER_71_197 VGND VGND VPWR VPWR sky130_fd_sc_hd__decap_3
XFILLER_12_242 VGND VGND VPWR VPWR sky130_fd_sc_hd__decap_3
XFILLER_12_253 VGND VGND VPWR VPWR sky130_fd_sc_hd__decap_3
XFILLER_100_80 VGND VGND VPWR VPWR sky130_fd_sc_hd__decap_3
XFILLER_12_275 VGND VGND VPWR VPWR sky130_fd_sc_hd__decap_3
XFILLER_12_297 VGND VGND VPWR VPWR sky130_fd_sc_hd__decap_3
XFILLER_8_224 VGND VGND VPWR VPWR sky130_fd_sc_hd__decap_3
XFILLER_8_268 VGND VGND VPWR VPWR sky130_fd_sc_hd__decap_3
XFILLER_106_380 VGND VGND VPWR VPWR sky130_fd_sc_hd__decap_3
XFILLER_69_60 VGND VGND VPWR VPWR sky130_fd_sc_hd__decap_3
XFILLER_79_220 VGND VGND VPWR VPWR sky130_fd_sc_hd__decap_3
XFILLER_79_253 VGND VGND VPWR VPWR sky130_fd_sc_hd__decap_3
XFILLER_79_275 VGND VGND VPWR VPWR sky130_fd_sc_hd__decap_3
XFILLER_39_128 VGND VGND VPWR VPWR sky130_fd_sc_hd__decap_3
XFILLER_67_437 VGND VGND VPWR VPWR sky130_fd_sc_hd__decap_3
XFILLER_48_640 VGND VGND VPWR VPWR sky130_fd_sc_hd__decap_3
XFILLER_82_418 VGND VGND VPWR VPWR sky130_fd_sc_hd__fill_2
XFILLER_94_256 VGND VGND VPWR VPWR sky130_fd_sc_hd__decap_3
XFILLER_47_161 VGND VGND VPWR VPWR sky130_fd_sc_hd__decap_3
XFILLER_47_172 VGND VGND VPWR VPWR sky130_fd_sc_hd__decap_3
XFILLER_63_610 VGND VGND VPWR VPWR sky130_fd_sc_hd__decap_3
XFILLER_63_632 VGND VGND VPWR VPWR sky130_fd_sc_hd__decap_3
XFILLER_75_481 VGND VGND VPWR VPWR sky130_fd_sc_hd__fill_2
XTAP_TAPCELL_ROW_85_1213 VGND VPWR sky130_fd_sc_hd__tapvpwrvgnd_1
XFILLER_35_334 VGND VGND VPWR VPWR sky130_fd_sc_hd__fill_2
XFILLER_75_492 VGND VGND VPWR VPWR sky130_fd_sc_hd__decap_3
XFILLER_35_367 VGND VGND VPWR VPWR sky130_fd_sc_hd__decap_3
X_6760_ _7071_/CLK _6760_/D VGND VGND VPWR VPWR _6760_/Q sky130_fd_sc_hd__dfxtp_2
XFILLER_16_592 VGND VGND VPWR VPWR sky130_fd_sc_hd__decap_3
XFILLER_50_326 VGND VGND VPWR VPWR sky130_fd_sc_hd__decap_3
XFILLER_62_197 VGND VGND VPWR VPWR sky130_fd_sc_hd__fill_1
X_6691_ _7349_/CLK _6691_/D VGND VGND VPWR VPWR _6691_/Q sky130_fd_sc_hd__dfxtp_2
XFILLER_31_595 VGND VGND VPWR VPWR sky130_fd_sc_hd__decap_3
X_5642_ _5642_/A _5642_/B VGND VGND VPWR VPWR _5643_/A sky130_fd_sc_hd__or2_2
X_5573_ hold973/X _4983_/A _4975_/Y VGND VGND VPWR VPWR _7044_/D sky130_fd_sc_hd__o21a_2
X_7312_ _7352_/CLK _7312_/D _6592_/Y VGND VGND VPWR VPWR _7312_/Q sky130_fd_sc_hd__dfrtp_2
X_4524_ _4524_/A0 _4591_/A _4528_/B VGND VGND VPWR VPWR _7317_/D sky130_fd_sc_hd__mux2_2
XTAP_TAPCELL_ROW_96_1342 VGND VPWR sky130_fd_sc_hd__tapvpwrvgnd_1
X_7243_ _7363_/CLK _7243_/D _6523_/Y VGND VGND VPWR VPWR _7243_/Q sky130_fd_sc_hd__dfrtp_2
X_4455_ _4069_/Y _4081_/X _4082_/X _4454_/X VGND VGND VPWR VPWR _4720_/B sky130_fd_sc_hd__o211a_2
X_7174_ _7366_/CLK _7174_/D _6454_/Y VGND VGND VPWR VPWR _7174_/Q sky130_fd_sc_hd__dfrtp_2
X_4386_ _7305_/Q _4488_/S _4437_/B1 _7369_/Q _4429_/C1 VGND VGND VPWR VPWR _4386_/X
+ sky130_fd_sc_hd__a221o_2
X_3406_ _3409_/D VGND VGND VPWR VPWR _3417_/C sky130_fd_sc_hd__inv_4
XFILLER_105_14 VGND VGND VPWR VPWR sky130_fd_sc_hd__decap_3
XFILLER_100_545 VGND VGND VPWR VPWR sky130_fd_sc_hd__decap_3
XFILLER_105_47 VGND VGND VPWR VPWR sky130_fd_sc_hd__decap_3
XFILLER_58_437 VGND VGND VPWR VPWR sky130_fd_sc_hd__decap_3
XFILLER_85_234 VGND VGND VPWR VPWR sky130_fd_sc_hd__decap_3
XFILLER_98_595 VGND VGND VPWR VPWR sky130_fd_sc_hd__decap_3
XFILLER_105_69 VGND VGND VPWR VPWR sky130_fd_sc_hd__decap_3
XFILLER_85_256 VGND VGND VPWR VPWR sky130_fd_sc_hd__decap_3
XFILLER_100_589 VGND VGND VPWR VPWR sky130_fd_sc_hd__decap_3
XFILLER_26_312 VGND VGND VPWR VPWR sky130_fd_sc_hd__decap_3
XFILLER_38_150 VGND VGND VPWR VPWR sky130_fd_sc_hd__decap_3
XFILLER_73_429 VGND VGND VPWR VPWR sky130_fd_sc_hd__decap_3
X_5007_ _5002_/Y _5003_/X _5004_/X _5005_/Y _5006_/X VGND VGND VPWR VPWR _5662_/A
+ sky130_fd_sc_hd__a221o_2
XFILLER_54_632 VGND VGND VPWR VPWR sky130_fd_sc_hd__decap_3
XFILLER_53_153 VGND VGND VPWR VPWR sky130_fd_sc_hd__decap_3
XFILLER_53_175 VGND VGND VPWR VPWR sky130_fd_sc_hd__decap_3
XFILLER_81_473 VGND VGND VPWR VPWR sky130_fd_sc_hd__decap_3
XFILLER_41_326 VGND VGND VPWR VPWR sky130_fd_sc_hd__decap_3
XFILLER_41_337 VGND VGND VPWR VPWR sky130_fd_sc_hd__fill_1
X_6958_ _6958_/CLK _6958_/D VGND VGND VPWR VPWR _6958_/Q sky130_fd_sc_hd__dfxtp_2
XTAP_TAPCELL_ROW_52_833 VGND VPWR sky130_fd_sc_hd__tapvpwrvgnd_1
XTAP_TAPCELL_ROW_24_513 VGND VPWR sky130_fd_sc_hd__tapvpwrvgnd_1
X_6889_ _7083_/CLK _6889_/D VGND VGND VPWR VPWR _6889_/Q sky130_fd_sc_hd__dfxtp_2
XFILLER_14_77 VGND VGND VPWR VPWR sky130_fd_sc_hd__decap_3
XFILLER_22_595 VGND VGND VPWR VPWR sky130_fd_sc_hd__decap_3
XPHY_EDGE_ROW_101_Left_210 VGND VGND VPWR VPWR sky130_fd_sc_hd__decap_3
XFILLER_14_88 VGND VGND VPWR VPWR sky130_fd_sc_hd__decap_3
XFILLER_108_645 VGND VGND VPWR VPWR sky130_fd_sc_hd__decap_3
Xhold780 _6937_/Q VGND VGND VPWR VPWR _6937_/D sky130_fd_sc_hd__dlygate4sd3_1
Xhold791 _6916_/Q VGND VGND VPWR VPWR _6916_/D sky130_fd_sc_hd__dlygate4sd3_1
XFILLER_89_551 VGND VGND VPWR VPWR sky130_fd_sc_hd__decap_3
XFILLER_39_63 VGND VGND VPWR VPWR sky130_fd_sc_hd__decap_3
XFILLER_49_437 VGND VGND VPWR VPWR sky130_fd_sc_hd__decap_3
XFILLER_76_212 VGND VGND VPWR VPWR sky130_fd_sc_hd__decap_3
XFILLER_39_96 VGND VGND VPWR VPWR sky130_fd_sc_hd__decap_3
XFILLER_64_407 VGND VGND VPWR VPWR sky130_fd_sc_hd__decap_3
XFILLER_76_256 VGND VGND VPWR VPWR sky130_fd_sc_hd__decap_3
XFILLER_17_301 VGND VGND VPWR VPWR sky130_fd_sc_hd__decap_3
XFILLER_29_172 VGND VGND VPWR VPWR sky130_fd_sc_hd__decap_3
XFILLER_64_429 VGND VGND VPWR VPWR sky130_fd_sc_hd__decap_3
XFILLER_76_289 VGND VGND VPWR VPWR sky130_fd_sc_hd__fill_2
XFILLER_91_215 VGND VGND VPWR VPWR sky130_fd_sc_hd__decap_3
XTAP_TAPCELL_ROW_4_282 VGND VPWR sky130_fd_sc_hd__tapvpwrvgnd_1
XFILLER_45_632 VGND VGND VPWR VPWR sky130_fd_sc_hd__decap_3
XFILLER_91_237 VGND VGND VPWR VPWR sky130_fd_sc_hd__decap_3
XFILLER_17_367 VGND VGND VPWR VPWR sky130_fd_sc_hd__fill_2
XFILLER_32_304 VGND VGND VPWR VPWR sky130_fd_sc_hd__fill_1
XFILLER_44_153 VGND VGND VPWR VPWR sky130_fd_sc_hd__decap_3
XFILLER_72_473 VGND VGND VPWR VPWR sky130_fd_sc_hd__decap_3
XFILLER_32_326 VGND VGND VPWR VPWR sky130_fd_sc_hd__decap_3
XFILLER_44_197 VGND VGND VPWR VPWR sky130_fd_sc_hd__decap_3
XFILLER_60_624 VGND VGND VPWR VPWR sky130_fd_sc_hd__decap_3
XFILLER_9_500 VGND VGND VPWR VPWR sky130_fd_sc_hd__decap_3
XFILLER_13_573 VGND VGND VPWR VPWR sky130_fd_sc_hd__decap_3
XTAP_TAPCELL_ROW_80_1154 VGND VPWR sky130_fd_sc_hd__tapvpwrvgnd_1
XFILLER_9_588 VGND VGND VPWR VPWR sky130_fd_sc_hd__decap_3
X_4240_ _4628_/A _4629_/B VGND VGND VPWR VPWR _4241_/B sky130_fd_sc_hd__and2_2
XFILLER_99_337 VGND VGND VPWR VPWR sky130_fd_sc_hd__decap_3
XFILLER_101_309 VGND VGND VPWR VPWR sky130_fd_sc_hd__decap_3
X_4171_ _4203_/A _4203_/B _4202_/A VGND VGND VPWR VPWR _4379_/B sky130_fd_sc_hd__a21oi_2
XTAP_TAPCELL_ROW_91_1283 VGND VPWR sky130_fd_sc_hd__tapvpwrvgnd_1
XFILLER_96_80 VGND VGND VPWR VPWR sky130_fd_sc_hd__decap_3
XFILLER_95_532 VGND VGND VPWR VPWR sky130_fd_sc_hd__fill_2
XFILLER_95_554 VGND VGND VPWR VPWR sky130_fd_sc_hd__decap_3
XFILLER_55_418 VGND VGND VPWR VPWR sky130_fd_sc_hd__decap_3
XFILLER_95_598 VGND VGND VPWR VPWR sky130_fd_sc_hd__decap_3
XFILLER_36_632 VGND VGND VPWR VPWR sky130_fd_sc_hd__decap_3
XFILLER_82_248 VGND VGND VPWR VPWR sky130_fd_sc_hd__decap_3
XFILLER_82_259 VGND VGND VPWR VPWR sky130_fd_sc_hd__fill_1
XFILLER_35_142 VGND VGND VPWR VPWR sky130_fd_sc_hd__decap_3
Xplace440 _5647_/A VGND VGND VPWR VPWR _4909_/A sky130_fd_sc_hd__buf_2
X_6812_ clkload6/A _6812_/D VGND VGND VPWR VPWR _6812_/Q sky130_fd_sc_hd__dfxtp_2
XFILLER_23_348 VGND VGND VPWR VPWR sky130_fd_sc_hd__decap_3
XFILLER_51_635 VGND VGND VPWR VPWR sky130_fd_sc_hd__decap_3
Xplace451 _3371_/A VGND VGND VPWR VPWR _5135_/A1 sky130_fd_sc_hd__buf_2
XFILLER_50_156 VGND VGND VPWR VPWR sky130_fd_sc_hd__decap_3
X_6743_ _6968_/CLK _6743_/D VGND VGND VPWR VPWR _6743_/Q sky130_fd_sc_hd__dfxtp_2
XFILLER_31_370 VGND VGND VPWR VPWR sky130_fd_sc_hd__decap_3
X_6674_ _6677_/A VGND VGND VPWR VPWR _6674_/Y sky130_fd_sc_hd__inv_2
X_3886_ _6920_/Q _3886_/A2 _3886_/B1 _6784_/Q VGND VGND VPWR VPWR _3886_/X sky130_fd_sc_hd__a22o_2
XTAP_TAPCELL_ROW_100_1390 VGND VPWR sky130_fd_sc_hd__tapvpwrvgnd_1
XFILLER_105_626 VGND VGND VPWR VPWR sky130_fd_sc_hd__decap_3
X_4507_ _4507_/A0 _7294_/Q _4520_/S VGND VGND VPWR VPWR _7326_/D sky130_fd_sc_hd__mux2_2
XFILLER_104_147 VGND VGND VPWR VPWR sky130_fd_sc_hd__decap_3
X_7226_ _7352_/CLK _7226_/D _6506_/Y VGND VGND VPWR VPWR _7226_/Q sky130_fd_sc_hd__dfrtp_2
X_4438_ _4434_/X _4437_/X _4425_/A VGND VGND VPWR VPWR _4650_/B sky130_fd_sc_hd__o21a_2
X_7157_ _7349_/CLK _7157_/D _6437_/Y VGND VGND VPWR VPWR _7157_/Q sky130_fd_sc_hd__dfrtp_2
X_4369_ _4369_/A _4369_/B VGND VGND VPWR VPWR _4369_/Y sky130_fd_sc_hd__nor2_2
XFILLER_98_392 VGND VGND VPWR VPWR sky130_fd_sc_hd__decap_3
XFILLER_46_407 VGND VGND VPWR VPWR sky130_fd_sc_hd__fill_1
XFILLER_58_256 VGND VGND VPWR VPWR sky130_fd_sc_hd__decap_3
XFILLER_86_576 VGND VGND VPWR VPWR sky130_fd_sc_hd__decap_3
X_7088_ _7352_/CLK _7088_/D _6368_/Y VGND VGND VPWR VPWR _7088_/Q sky130_fd_sc_hd__dfrtp_2
XFILLER_58_289 VGND VGND VPWR VPWR sky130_fd_sc_hd__decap_3
XFILLER_73_204 VGND VGND VPWR VPWR sky130_fd_sc_hd__decap_3
XFILLER_26_120 VGND VGND VPWR VPWR sky130_fd_sc_hd__decap_3
XFILLER_27_632 VGND VGND VPWR VPWR sky130_fd_sc_hd__decap_3
XFILLER_39_481 VGND VGND VPWR VPWR sky130_fd_sc_hd__decap_3
XFILLER_73_237 VGND VGND VPWR VPWR sky130_fd_sc_hd__decap_3
XFILLER_92_27 VGND VGND VPWR VPWR sky130_fd_sc_hd__fill_1
XTAP_TAPCELL_ROW_1_241 VGND VPWR sky130_fd_sc_hd__tapvpwrvgnd_1
XFILLER_14_304 VGND VGND VPWR VPWR sky130_fd_sc_hd__decap_3
XTAP_TAPCELL_ROW_37_660 VGND VPWR sky130_fd_sc_hd__tapvpwrvgnd_1
XFILLER_14_315 VGND VGND VPWR VPWR sky130_fd_sc_hd__fill_1
XFILLER_25_43 VGND VGND VPWR VPWR sky130_fd_sc_hd__decap_3
XFILLER_26_186 VGND VGND VPWR VPWR sky130_fd_sc_hd__decap_3
XFILLER_26_197 VGND VGND VPWR VPWR sky130_fd_sc_hd__decap_3
XFILLER_42_624 VGND VGND VPWR VPWR sky130_fd_sc_hd__decap_3
XFILLER_54_495 VGND VGND VPWR VPWR sky130_fd_sc_hd__decap_3
XFILLER_81_270 VGND VGND VPWR VPWR sky130_fd_sc_hd__fill_2
XFILLER_81_281 VGND VGND VPWR VPWR sky130_fd_sc_hd__decap_3
XTAP_TAPCELL_ROW_65_980 VGND VPWR sky130_fd_sc_hd__tapvpwrvgnd_1
XTAP_TAPCELL_ROW_103_1419 VGND VPWR sky130_fd_sc_hd__tapvpwrvgnd_1
XFILLER_14_348 VGND VGND VPWR VPWR sky130_fd_sc_hd__decap_3
XFILLER_41_167 VGND VGND VPWR VPWR sky130_fd_sc_hd__fill_1
XFILLER_41_178 VGND VGND VPWR VPWR sky130_fd_sc_hd__decap_3
XFILLER_10_521 VGND VGND VPWR VPWR sky130_fd_sc_hd__fill_2
XFILLER_10_543 VGND VGND VPWR VPWR sky130_fd_sc_hd__decap_3
XFILLER_10_598 VGND VGND VPWR VPWR sky130_fd_sc_hd__decap_3
XFILLER_6_569 VGND VGND VPWR VPWR sky130_fd_sc_hd__decap_3
XFILLER_108_475 VGND VGND VPWR VPWR sky130_fd_sc_hd__fill_1
XTAP_TAPCELL_ROW_9_341 VGND VPWR sky130_fd_sc_hd__tapvpwrvgnd_1
XFILLER_1_252 VGND VGND VPWR VPWR sky130_fd_sc_hd__fill_1
XFILLER_1_274 VGND VGND VPWR VPWR sky130_fd_sc_hd__decap_3
XFILLER_103_191 VGND VGND VPWR VPWR sky130_fd_sc_hd__decap_3
XFILLER_18_610 VGND VGND VPWR VPWR sky130_fd_sc_hd__decap_3
XFILLER_49_278 VGND VGND VPWR VPWR sky130_fd_sc_hd__fill_2
XFILLER_49_289 VGND VGND VPWR VPWR sky130_fd_sc_hd__fill_1
XTAP_TAPCELL_ROW_69_1027 VGND VPWR sky130_fd_sc_hd__tapvpwrvgnd_1
XFILLER_18_643 VGND VGND VPWR VPWR sky130_fd_sc_hd__fill_1
XFILLER_64_226 VGND VGND VPWR VPWR sky130_fd_sc_hd__fill_2
XFILLER_33_613 VGND VGND VPWR VPWR sky130_fd_sc_hd__decap_3
XFILLER_45_462 VGND VGND VPWR VPWR sky130_fd_sc_hd__fill_1
XFILLER_17_186 VGND VGND VPWR VPWR sky130_fd_sc_hd__decap_3
XFILLER_33_635 VGND VGND VPWR VPWR sky130_fd_sc_hd__decap_3
XFILLER_60_410 VGND VGND VPWR VPWR sky130_fd_sc_hd__decap_3
XFILLER_60_421 VGND VGND VPWR VPWR sky130_fd_sc_hd__decap_3
XFILLER_72_281 VGND VGND VPWR VPWR sky130_fd_sc_hd__decap_3
XFILLER_60_465 VGND VGND VPWR VPWR sky130_fd_sc_hd__decap_3
XFILLER_20_307 VGND VGND VPWR VPWR sky130_fd_sc_hd__fill_1
X_3740_ _6710_/Q _3911_/A2 _3911_/B1 _6888_/Q _3739_/X VGND VGND VPWR VPWR _3740_/X
+ sky130_fd_sc_hd__a221o_2
X_3671_ _3671_/A1 _4832_/A _3670_/X VGND VGND VPWR VPWR _7405_/D sky130_fd_sc_hd__o21a_2
X_6390_ _6618_/A VGND VGND VPWR VPWR _6390_/Y sky130_fd_sc_hd__inv_2
XFILLER_9_396 VGND VGND VPWR VPWR sky130_fd_sc_hd__decap_3
XTAP_TAPCELL_ROW_93_1301 VGND VPWR sky130_fd_sc_hd__tapvpwrvgnd_1
XFILLER_99_101 VGND VGND VPWR VPWR sky130_fd_sc_hd__decap_3
XFILLER_5_591 VGND VGND VPWR VPWR sky130_fd_sc_hd__decap_3
XFILLER_99_134 VGND VGND VPWR VPWR sky130_fd_sc_hd__decap_3
XFILLER_102_618 VGND VGND VPWR VPWR sky130_fd_sc_hd__decap_3
X_7011_ _7355_/CLK _7011_/D _6291_/Y VGND VGND VPWR VPWR _7011_/Q sky130_fd_sc_hd__dfrtp_2
X_5272_ _5272_/A0 _5061_/X _5274_/S VGND VGND VPWR VPWR _7194_/D sky130_fd_sc_hd__mux2_2
XFILLER_99_178 VGND VGND VPWR VPWR sky130_fd_sc_hd__decap_3
XFILLER_99_167 VGND VGND VPWR VPWR sky130_fd_sc_hd__fill_1
XFILLER_101_128 VGND VGND VPWR VPWR sky130_fd_sc_hd__fill_2
X_4223_ _4217_/X _4219_/X _4222_/X _4327_/A VGND VGND VPWR VPWR _4224_/C sky130_fd_sc_hd__o31a_2
XFILLER_95_340 VGND VGND VPWR VPWR sky130_fd_sc_hd__decap_3
X_4154_ _7047_/Q _4429_/A2 _4354_/B1 _7394_/Q _4153_/X VGND VGND VPWR VPWR _4154_/X
+ sky130_fd_sc_hd__a221o_2
XFILLER_68_598 VGND VGND VPWR VPWR sky130_fd_sc_hd__fill_2
XFILLER_95_373 VGND VGND VPWR VPWR sky130_fd_sc_hd__decap_3
X_4085_ _7238_/Q _4430_/A2 _4420_/B1 _7142_/Q _4084_/X VGND VGND VPWR VPWR _4085_/X
+ sky130_fd_sc_hd__a221o_2
XFILLER_102_15 VGND VGND VPWR VPWR sky130_fd_sc_hd__decap_3
XFILLER_24_613 VGND VGND VPWR VPWR sky130_fd_sc_hd__decap_3
XFILLER_51_410 VGND VGND VPWR VPWR sky130_fd_sc_hd__decap_3
XFILLER_23_156 VGND VGND VPWR VPWR sky130_fd_sc_hd__decap_3
XFILLER_51_443 VGND VGND VPWR VPWR sky130_fd_sc_hd__fill_2
Xplace281 _3661_/X VGND VGND VPWR VPWR _3888_/A2 sky130_fd_sc_hd__buf_2
Xplace270 _3911_/B1 VGND VGND VPWR VPWR _3912_/B1 sky130_fd_sc_hd__buf_2
XTAP_TAPCELL_ROW_62_950 VGND VPWR sky130_fd_sc_hd__tapvpwrvgnd_1
XTAP_TAPCELL_ROW_34_630 VGND VPWR sky130_fd_sc_hd__tapvpwrvgnd_1
XFILLER_11_329 VGND VGND VPWR VPWR sky130_fd_sc_hd__decap_3
XFILLER_23_178 VGND VGND VPWR VPWR sky130_fd_sc_hd__decap_3
Xplace292 _3883_/A2 VGND VGND VPWR VPWR _3824_/B1 sky130_fd_sc_hd__buf_2
X_6726_ _6976_/CLK _6726_/D VGND VGND VPWR VPWR _6726_/Q sky130_fd_sc_hd__dfxtp_2
X_4987_ _4987_/A _4987_/B VGND VGND VPWR VPWR _4987_/Y sky130_fd_sc_hd__xnor2_2
X_6657_ _6667_/A VGND VGND VPWR VPWR _6657_/Y sky130_fd_sc_hd__inv_2
X_3869_ _6772_/Q _3912_/A2 _3911_/B1 _6766_/Q VGND VGND VPWR VPWR _3869_/X sky130_fd_sc_hd__a22o_2
X_6588_ _6589_/A VGND VGND VPWR VPWR _6588_/Y sky130_fd_sc_hd__inv_2
XFILLER_105_423 VGND VGND VPWR VPWR sky130_fd_sc_hd__decap_3
XFILLER_105_467 VGND VGND VPWR VPWR sky130_fd_sc_hd__decap_3
XFILLER_78_307 VGND VGND VPWR VPWR sky130_fd_sc_hd__fill_1
XTAP_TAPCELL_ROW_6_300 VGND VPWR sky130_fd_sc_hd__tapvpwrvgnd_1
XFILLER_105_489 VGND VGND VPWR VPWR sky130_fd_sc_hd__decap_3
X_7209_ _7406_/CLK _7209_/D _6489_/Y VGND VGND VPWR VPWR _7209_/Q sky130_fd_sc_hd__dfrtp_2
XFILLER_100_150 VGND VGND VPWR VPWR sky130_fd_sc_hd__decap_3
XFILLER_100_161 VGND VGND VPWR VPWR sky130_fd_sc_hd__decap_3
XFILLER_19_429 VGND VGND VPWR VPWR sky130_fd_sc_hd__decap_3
XFILLER_100_194 VGND VGND VPWR VPWR sky130_fd_sc_hd__fill_2
XFILLER_36_42 VGND VGND VPWR VPWR sky130_fd_sc_hd__decap_3
XFILLER_46_259 VGND VGND VPWR VPWR sky130_fd_sc_hd__decap_3
XFILLER_14_112 VGND VGND VPWR VPWR sky130_fd_sc_hd__decap_3
XFILLER_15_635 VGND VGND VPWR VPWR sky130_fd_sc_hd__decap_3
XFILLER_42_421 VGND VGND VPWR VPWR sky130_fd_sc_hd__fill_1
XFILLER_54_270 VGND VGND VPWR VPWR sky130_fd_sc_hd__decap_3
XFILLER_14_167 VGND VGND VPWR VPWR sky130_fd_sc_hd__decap_3
XFILLER_14_178 VGND VGND VPWR VPWR sky130_fd_sc_hd__decap_3
XFILLER_30_616 VGND VGND VPWR VPWR sky130_fd_sc_hd__decap_3
XFILLER_52_85 VGND VGND VPWR VPWR sky130_fd_sc_hd__decap_3
XFILLER_10_340 VGND VGND VPWR VPWR sky130_fd_sc_hd__decap_3
XTAP_TAPCELL_ROW_12_368 VGND VPWR sky130_fd_sc_hd__tapvpwrvgnd_1
XFILLER_10_395 VGND VGND VPWR VPWR sky130_fd_sc_hd__decap_3
XFILLER_6_333 VGND VGND VPWR VPWR sky130_fd_sc_hd__fill_2
XTAP_TAPCELL_ROW_40_699 VGND VPWR sky130_fd_sc_hd__tapvpwrvgnd_1
XFILLER_108_250 VGND VGND VPWR VPWR sky130_fd_sc_hd__fill_2
XFILLER_6_355 VGND VGND VPWR VPWR sky130_fd_sc_hd__decap_3
XFILLER_6_388 VGND VGND VPWR VPWR sky130_fd_sc_hd__decap_3
XFILLER_2_572 VGND VGND VPWR VPWR sky130_fd_sc_hd__decap_3
XFILLER_69_318 VGND VGND VPWR VPWR sky130_fd_sc_hd__decap_3
XTAP_TAPCELL_ROW_75_1097 VGND VPWR sky130_fd_sc_hd__tapvpwrvgnd_1
XFILLER_96_126 VGND VGND VPWR VPWR sky130_fd_sc_hd__decap_3
XFILLER_96_104 VGND VGND VPWR VPWR sky130_fd_sc_hd__decap_3
XFILLER_77_340 VGND VGND VPWR VPWR sky130_fd_sc_hd__decap_3
XFILLER_65_502 VGND VGND VPWR VPWR sky130_fd_sc_hd__fill_2
XFILLER_37_237 VGND VGND VPWR VPWR sky130_fd_sc_hd__decap_3
XFILLER_92_321 VGND VGND VPWR VPWR sky130_fd_sc_hd__fill_2
XFILLER_37_259 VGND VGND VPWR VPWR sky130_fd_sc_hd__decap_3
XFILLER_52_207 VGND VGND VPWR VPWR sky130_fd_sc_hd__decap_3
XFILLER_92_365 VGND VGND VPWR VPWR sky130_fd_sc_hd__decap_3
XFILLER_18_473 VGND VGND VPWR VPWR sky130_fd_sc_hd__decap_3
XFILLER_45_270 VGND VGND VPWR VPWR sky130_fd_sc_hd__decap_3
XFILLER_45_281 VGND VGND VPWR VPWR sky130_fd_sc_hd__decap_3
XFILLER_92_387 VGND VGND VPWR VPWR sky130_fd_sc_hd__decap_3
X_4910_ _5092_/C _4910_/B VGND VGND VPWR VPWR _4910_/Y sky130_fd_sc_hd__nand2_2
XTAP_TAPCELL_ROW_48_788 VGND VPWR sky130_fd_sc_hd__tapvpwrvgnd_1
X_4841_ _4890_/B _4888_/B VGND VGND VPWR VPWR _4841_/Y sky130_fd_sc_hd__nand2b_2
XFILLER_21_605 VGND VGND VPWR VPWR sky130_fd_sc_hd__decap_3
XFILLER_21_638 VGND VGND VPWR VPWR sky130_fd_sc_hd__decap_3
XFILLER_33_476 VGND VGND VPWR VPWR sky130_fd_sc_hd__decap_3
XFILLER_60_262 VGND VGND VPWR VPWR sky130_fd_sc_hd__decap_3
XFILLER_20_115 VGND VGND VPWR VPWR sky130_fd_sc_hd__decap_3
XFILLER_60_295 VGND VGND VPWR VPWR sky130_fd_sc_hd__decap_3
X_4772_ _4772_/A0 _4771_/X _4946_/S VGND VGND VPWR VPWR _7275_/D sky130_fd_sc_hd__mux2_2
X_6511_ _6644_/A VGND VGND VPWR VPWR _6511_/Y sky130_fd_sc_hd__inv_2
X_3723_ _6813_/Q _3913_/B1 _3881_/B1 _6823_/Q VGND VGND VPWR VPWR _3723_/X sky130_fd_sc_hd__a22o_2
X_6442_ _6638_/A VGND VGND VPWR VPWR _6442_/Y sky130_fd_sc_hd__inv_2
XFILLER_9_193 VGND VGND VPWR VPWR sky130_fd_sc_hd__decap_3
X_6373_ _6566_/A VGND VGND VPWR VPWR _6373_/Y sky130_fd_sc_hd__inv_2
X_3585_ _3586_/A _3591_/B _3591_/C _3586_/D VGND VGND VPWR VPWR _3599_/A sky130_fd_sc_hd__o31a_2
XFILLER_88_638 VGND VGND VPWR VPWR sky130_fd_sc_hd__decap_3
XFILLER_102_448 VGND VGND VPWR VPWR sky130_fd_sc_hd__decap_3
XFILLER_68_340 VGND VGND VPWR VPWR sky130_fd_sc_hd__decap_3
XFILLER_87_137 VGND VGND VPWR VPWR sky130_fd_sc_hd__decap_3
X_4206_ _4920_/A _4204_/Y _4205_/X VGND VGND VPWR VPWR _4206_/X sky130_fd_sc_hd__a21o_2
X_5186_ _5186_/A _5186_/B VGND VGND VPWR VPWR _7235_/D sky130_fd_sc_hd__and2_2
XFILLER_28_248 VGND VGND VPWR VPWR sky130_fd_sc_hd__decap_3
XFILLER_56_557 VGND VGND VPWR VPWR sky130_fd_sc_hd__decap_3
XFILLER_95_181 VGND VGND VPWR VPWR sky130_fd_sc_hd__decap_3
X_4137_ _7048_/Q _4488_/S _4399_/A2 _7395_/Q _4136_/X VGND VGND VPWR VPWR _4137_/X
+ sky130_fd_sc_hd__a221o_2
XFILLER_28_259 VGND VGND VPWR VPWR sky130_fd_sc_hd__decap_3
XFILLER_83_343 VGND VGND VPWR VPWR sky130_fd_sc_hd__decap_3
XFILLER_83_376 VGND VGND VPWR VPWR sky130_fd_sc_hd__decap_3
X_4068_ _4068_/A _4082_/A VGND VGND VPWR VPWR _4069_/B sky130_fd_sc_hd__nor2_2
XFILLER_24_421 VGND VGND VPWR VPWR sky130_fd_sc_hd__decap_3
XFILLER_12_616 VGND VGND VPWR VPWR sky130_fd_sc_hd__decap_3
XFILLER_24_465 VGND VGND VPWR VPWR sky130_fd_sc_hd__decap_3
XFILLER_51_273 VGND VGND VPWR VPWR sky130_fd_sc_hd__decap_3
XFILLER_11_126 VGND VGND VPWR VPWR sky130_fd_sc_hd__decap_3
XFILLER_24_498 VGND VGND VPWR VPWR sky130_fd_sc_hd__decap_3
XFILLER_51_284 VGND VGND VPWR VPWR sky130_fd_sc_hd__decap_3
X_6709_ _6965_/CLK _6709_/D VGND VGND VPWR VPWR _6709_/Q sky130_fd_sc_hd__dfxtp_2
XFILLER_22_55 VGND VGND VPWR VPWR sky130_fd_sc_hd__fill_1
XFILLER_22_88 VGND VGND VPWR VPWR sky130_fd_sc_hd__decap_3
XFILLER_3_303 VGND VGND VPWR VPWR sky130_fd_sc_hd__decap_3
XFILLER_105_231 VGND VGND VPWR VPWR sky130_fd_sc_hd__decap_3
XFILLER_3_369 VGND VGND VPWR VPWR sky130_fd_sc_hd__decap_3
XFILLER_105_275 VGND VGND VPWR VPWR sky130_fd_sc_hd__decap_3
XFILLER_78_126 VGND VGND VPWR VPWR sky130_fd_sc_hd__decap_3
XFILLER_78_137 VGND VGND VPWR VPWR sky130_fd_sc_hd__decap_3
Xoutput490 _3378_/A VGND VGND VPWR VPWR instruction_out[10] sky130_fd_sc_hd__clkdlybuf4s25_1
XFILLER_59_351 VGND VGND VPWR VPWR sky130_fd_sc_hd__fill_2
XFILLER_59_362 VGND VGND VPWR VPWR sky130_fd_sc_hd__decap_3
XFILLER_101_470 VGND VGND VPWR VPWR sky130_fd_sc_hd__decap_3
XFILLER_47_535 VGND VGND VPWR VPWR sky130_fd_sc_hd__decap_3
XFILLER_93_129 VGND VGND VPWR VPWR sky130_fd_sc_hd__decap_3
XFILLER_19_248 VGND VGND VPWR VPWR sky130_fd_sc_hd__decap_3
XFILLER_34_207 VGND VGND VPWR VPWR sky130_fd_sc_hd__decap_3
XFILLER_47_74 VGND VGND VPWR VPWR sky130_fd_sc_hd__fill_1
XFILLER_74_365 VGND VGND VPWR VPWR sky130_fd_sc_hd__decap_3
XTAP_TAPCELL_ROW_17_427 VGND VPWR sky130_fd_sc_hd__tapvpwrvgnd_1
XFILLER_27_281 VGND VGND VPWR VPWR sky130_fd_sc_hd__fill_2
XTAP_TAPCELL_ROW_45_747 VGND VPWR sky130_fd_sc_hd__tapvpwrvgnd_1
XFILLER_42_273 VGND VGND VPWR VPWR sky130_fd_sc_hd__fill_1
XFILLER_15_498 VGND VGND VPWR VPWR sky130_fd_sc_hd__decap_3
XFILLER_30_446 VGND VGND VPWR VPWR sky130_fd_sc_hd__decap_3
XFILLER_42_284 VGND VGND VPWR VPWR sky130_fd_sc_hd__decap_3
XFILLER_8_24 VGND VGND VPWR VPWR sky130_fd_sc_hd__decap_3
XFILLER_30_468 VGND VGND VPWR VPWR sky130_fd_sc_hd__decap_3
XFILLER_7_620 VGND VGND VPWR VPWR sky130_fd_sc_hd__decap_3
Xhold609 _6918_/Q VGND VGND VPWR VPWR _6918_/D sky130_fd_sc_hd__dlygate4sd3_1
Xwire562 _3576_/Y VGND VGND VPWR VPWR _3591_/B sky130_fd_sc_hd__clkbuf_2
XTAP_TAPCELL_ROW_77_1115 VGND VPWR sky130_fd_sc_hd__tapvpwrvgnd_1
XFILLER_6_163 VGND VGND VPWR VPWR sky130_fd_sc_hd__decap_3
X_3370_ _3561_/A _6983_/Q VGND VGND VPWR VPWR _3370_/Y sky130_fd_sc_hd__nor2_2
XFILLER_97_402 VGND VGND VPWR VPWR sky130_fd_sc_hd__decap_3
XFILLER_69_159 VGND VGND VPWR VPWR sky130_fd_sc_hd__decap_3
X_5040_ _6989_/D _5039_/X _5156_/S VGND VGND VPWR VPWR _5040_/X sky130_fd_sc_hd__mux2_2
XFILLER_97_479 VGND VGND VPWR VPWR sky130_fd_sc_hd__decap_3
XFILLER_65_310 VGND VGND VPWR VPWR sky130_fd_sc_hd__decap_3
XFILLER_77_181 VGND VGND VPWR VPWR sky130_fd_sc_hd__decap_3
XFILLER_93_641 VGND VGND VPWR VPWR sky130_fd_sc_hd__decap_3
XFILLER_53_505 VGND VGND VPWR VPWR sky130_fd_sc_hd__decap_3
X_6991_ _7397_/CLK _6991_/D _6271_/Y VGND VGND VPWR VPWR _6991_/Q sky130_fd_sc_hd__dfrtp_2
XTAP_TAPCELL_ROW_88_1244 VGND VPWR sky130_fd_sc_hd__tapvpwrvgnd_1
XFILLER_53_538 VGND VGND VPWR VPWR sky130_fd_sc_hd__decap_3
XFILLER_92_162 VGND VGND VPWR VPWR sky130_fd_sc_hd__decap_3
XFILLER_18_281 VGND VGND VPWR VPWR sky130_fd_sc_hd__decap_3
XFILLER_80_346 VGND VGND VPWR VPWR sky130_fd_sc_hd__decap_3
XFILLER_21_446 VGND VGND VPWR VPWR sky130_fd_sc_hd__fill_2
XFILLER_33_273 VGND VGND VPWR VPWR sky130_fd_sc_hd__decap_3
XFILLER_33_284 VGND VGND VPWR VPWR sky130_fd_sc_hd__fill_2
X_4755_ _7005_/Q _4775_/A VGND VGND VPWR VPWR _7005_/D sky130_fd_sc_hd__xor2_2
X_4686_ _6999_/Q _7000_/Q _4858_/B VGND VGND VPWR VPWR _4687_/B sky130_fd_sc_hd__and3_2
XTAP_TAPCELL_ROW_99_1373 VGND VPWR sky130_fd_sc_hd__tapvpwrvgnd_1
X_6425_ _6554_/A VGND VGND VPWR VPWR _6425_/Y sky130_fd_sc_hd__inv_2
X_3637_ _3636_/Y _3605_/Y _3505_/X _3618_/X VGND VGND VPWR VPWR _3637_/X sky130_fd_sc_hd__a22o_2
X_6356_ _6684_/A VGND VGND VPWR VPWR _6356_/Y sky130_fd_sc_hd__inv_2
X_3568_ _7093_/Q _3417_/X _3407_/X _7125_/Q VGND VGND VPWR VPWR _3568_/X sky130_fd_sc_hd__a22o_2
XFILLER_0_317 VGND VGND VPWR VPWR sky130_fd_sc_hd__decap_3
XFILLER_102_223 VGND VGND VPWR VPWR sky130_fd_sc_hd__decap_3
XFILLER_88_457 VGND VGND VPWR VPWR sky130_fd_sc_hd__decap_3
X_6287_ _6524_/A VGND VGND VPWR VPWR _6287_/Y sky130_fd_sc_hd__inv_2
X_3499_ _4537_/C _5708_/S _3497_/X _5152_/B VGND VGND VPWR VPWR _3541_/B sky130_fd_sc_hd__a31oi_4
XFILLER_102_256 VGND VGND VPWR VPWR sky130_fd_sc_hd__decap_3
X_5238_ _5362_/C _5238_/B _5229_/C VGND VGND VPWR VPWR _5238_/X sky130_fd_sc_hd__or3b_2
XFILLER_75_129 VGND VGND VPWR VPWR sky130_fd_sc_hd__fill_2
X_5169_ _5169_/A _5186_/B VGND VGND VPWR VPWR _7243_/D sky130_fd_sc_hd__and2_2
XFILLER_56_365 VGND VGND VPWR VPWR sky130_fd_sc_hd__decap_3
XFILLER_83_140 VGND VGND VPWR VPWR sky130_fd_sc_hd__decap_3
XFILLER_16_207 VGND VGND VPWR VPWR sky130_fd_sc_hd__decap_3
XFILLER_71_302 VGND VGND VPWR VPWR sky130_fd_sc_hd__decap_3
XFILLER_83_162 VGND VGND VPWR VPWR sky130_fd_sc_hd__decap_3
XFILLER_83_184 VGND VGND VPWR VPWR sky130_fd_sc_hd__decap_3
XFILLER_17_66 VGND VGND VPWR VPWR sky130_fd_sc_hd__decap_3
XFILLER_17_88 VGND VGND VPWR VPWR sky130_fd_sc_hd__decap_3
XFILLER_71_335 VGND VGND VPWR VPWR sky130_fd_sc_hd__fill_1
XTAP_TAPCELL_ROW_108_1491 VGND VPWR sky130_fd_sc_hd__tapvpwrvgnd_1
XTAP_TAPCELL_ROW_108_1480 VGND VPWR sky130_fd_sc_hd__tapvpwrvgnd_1
XFILLER_12_402 VGND VGND VPWR VPWR sky130_fd_sc_hd__decap_3
XFILLER_24_262 VGND VGND VPWR VPWR sky130_fd_sc_hd__fill_1
XTAP_TAPCELL_ROW_42_717 VGND VPWR sky130_fd_sc_hd__tapvpwrvgnd_1
XFILLER_12_435 VGND VGND VPWR VPWR sky130_fd_sc_hd__decap_3
XFILLER_33_87 VGND VGND VPWR VPWR sky130_fd_sc_hd__fill_2
XTAP_TAPCELL_ROW_22_485 VGND VPWR sky130_fd_sc_hd__tapvpwrvgnd_1
XFILLER_4_601 VGND VGND VPWR VPWR sky130_fd_sc_hd__decap_3
XFILLER_4_634 VGND VGND VPWR VPWR sky130_fd_sc_hd__decap_3
XFILLER_4_645 VGND VGND VPWR VPWR sky130_fd_sc_hd__decap_3
XFILLER_106_562 VGND VGND VPWR VPWR sky130_fd_sc_hd__decap_3
XFILLER_106_584 VGND VGND VPWR VPWR sky130_fd_sc_hd__decap_3
XFILLER_3_155 VGND VGND VPWR VPWR sky130_fd_sc_hd__decap_3
XFILLER_106_595 VGND VGND VPWR VPWR sky130_fd_sc_hd__decap_3
XFILLER_79_446 VGND VGND VPWR VPWR sky130_fd_sc_hd__fill_2
XTAP_TAPCELL_ROW_72_1067 VGND VPWR sky130_fd_sc_hd__tapvpwrvgnd_1
XFILLER_58_62 VGND VGND VPWR VPWR sky130_fd_sc_hd__decap_3
XFILLER_79_479 VGND VGND VPWR VPWR sky130_fd_sc_hd__decap_3
XFILLER_94_405 VGND VGND VPWR VPWR sky130_fd_sc_hd__decap_3
XFILLER_12_9 VGND VGND VPWR VPWR sky130_fd_sc_hd__fill_1
XFILLER_35_505 VGND VGND VPWR VPWR sky130_fd_sc_hd__fill_2
XFILLER_75_641 VGND VGND VPWR VPWR sky130_fd_sc_hd__decap_3
XFILLER_74_162 VGND VGND VPWR VPWR sky130_fd_sc_hd__decap_3
XFILLER_74_50 VGND VGND VPWR VPWR sky130_fd_sc_hd__fill_2
XFILLER_90_633 VGND VGND VPWR VPWR sky130_fd_sc_hd__decap_3
XFILLER_62_335 VGND VGND VPWR VPWR sky130_fd_sc_hd__decap_3
XFILLER_74_72 VGND VGND VPWR VPWR sky130_fd_sc_hd__decap_3
XFILLER_15_251 VGND VGND VPWR VPWR sky130_fd_sc_hd__decap_3
XFILLER_62_379 VGND VGND VPWR VPWR sky130_fd_sc_hd__decap_3
XFILLER_30_221 VGND VGND VPWR VPWR sky130_fd_sc_hd__decap_3
XTAP_TAPCELL_ROW_83_1185 VGND VPWR sky130_fd_sc_hd__tapvpwrvgnd_1
XFILLER_95_6 VGND VGND VPWR VPWR sky130_fd_sc_hd__decap_3
XFILLER_90_60 VGND VGND VPWR VPWR sky130_fd_sc_hd__fill_2
XFILLER_90_82 VGND VGND VPWR VPWR sky130_fd_sc_hd__fill_2
XFILLER_90_93 VGND VGND VPWR VPWR sky130_fd_sc_hd__fill_1
XFILLER_11_490 VGND VGND VPWR VPWR sky130_fd_sc_hd__decap_3
Xclkbuf_leaf_10_clk clkbuf_leaf_9_clk/A VGND VGND VPWR VPWR _6974_/CLK sky130_fd_sc_hd__clkbuf_16
X_4540_ _4540_/A _4563_/B VGND VGND VPWR VPWR _7310_/D sky130_fd_sc_hd__and2_2
X_4471_ _7343_/Q _4470_/X _4471_/S VGND VGND VPWR VPWR _7343_/D sky130_fd_sc_hd__mux2_2
X_7190_ _7348_/CLK _7190_/D _6470_/Y VGND VGND VPWR VPWR _7190_/Q sky130_fd_sc_hd__dfrtp_2
X_3353_ _6980_/Q _3353_/B VGND VGND VPWR VPWR _5668_/A sky130_fd_sc_hd__xor2_2
XFILLER_97_243 VGND VGND VPWR VPWR sky130_fd_sc_hd__decap_3
XFILLER_97_221 VGND VGND VPWR VPWR sky130_fd_sc_hd__decap_3
XFILLER_58_619 VGND VGND VPWR VPWR sky130_fd_sc_hd__decap_3
Xhold1106 _7335_/Q VGND VGND VPWR VPWR _4488_/A0 sky130_fd_sc_hd__dlygate4sd3_1
XFILLER_97_254 VGND VGND VPWR VPWR sky130_fd_sc_hd__decap_3
XFILLER_85_427 VGND VGND VPWR VPWR sky130_fd_sc_hd__decap_3
XFILLER_85_449 VGND VGND VPWR VPWR sky130_fd_sc_hd__decap_3
Xhold1117 _7155_/Q VGND VGND VPWR VPWR _5352_/A0 sky130_fd_sc_hd__dlygate4sd3_1
Xhold1128 _7176_/Q VGND VGND VPWR VPWR _5308_/A0 sky130_fd_sc_hd__dlygate4sd3_1
Xhold1139 _7289_/Q VGND VGND VPWR VPWR _4583_/A sky130_fd_sc_hd__dlygate4sd3_1
X_5023_ _5661_/A VGND VGND VPWR VPWR _5023_/Y sky130_fd_sc_hd__inv_2
XFILLER_26_505 VGND VGND VPWR VPWR sky130_fd_sc_hd__decap_3
XFILLER_65_151 VGND VGND VPWR VPWR sky130_fd_sc_hd__fill_1
XFILLER_65_162 VGND VGND VPWR VPWR sky130_fd_sc_hd__decap_3
XFILLER_65_184 VGND VGND VPWR VPWR sky130_fd_sc_hd__decap_3
XFILLER_80_121 VGND VGND VPWR VPWR sky130_fd_sc_hd__decap_3
XFILLER_81_644 VGND VGND VPWR VPWR sky130_fd_sc_hd__decap_3
X_6974_ _6974_/CLK _6974_/D VGND VGND VPWR VPWR _6974_/Q sky130_fd_sc_hd__dfxtp_2
XFILLER_80_154 VGND VGND VPWR VPWR sky130_fd_sc_hd__decap_3
XFILLER_21_210 VGND VGND VPWR VPWR sky130_fd_sc_hd__decap_3
XFILLER_80_187 VGND VGND VPWR VPWR sky130_fd_sc_hd__decap_3
X_4807_ _4807_/A0 _4806_/X _4946_/S VGND VGND VPWR VPWR _7273_/D sky130_fd_sc_hd__mux2_2
XPHY_EDGE_ROW_3_Right_3 VGND VGND VPWR VPWR sky130_fd_sc_hd__decap_3
X_4738_ _4738_/A _4738_/B VGND VGND VPWR VPWR _7006_/D sky130_fd_sc_hd__nor2_2
X_4669_ _6995_/Q _5628_/B VGND VGND VPWR VPWR _4928_/B sky130_fd_sc_hd__and2_2
XFILLER_79_28 VGND VGND VPWR VPWR sky130_fd_sc_hd__decap_3
Xhold940 _7046_/Q VGND VGND VPWR VPWR hold940/X sky130_fd_sc_hd__dlygate4sd3_1
X_6408_ _6636_/A VGND VGND VPWR VPWR _6408_/Y sky130_fd_sc_hd__inv_2
XFILLER_1_626 VGND VGND VPWR VPWR sky130_fd_sc_hd__decap_3
X_7388_ _7398_/CLK _7388_/D _6668_/Y VGND VGND VPWR VPWR _7388_/Q sky130_fd_sc_hd__dfrtp_2
Xhold973 _7044_/Q VGND VGND VPWR VPWR hold973/X sky130_fd_sc_hd__dlygate4sd3_1
Xhold962 _7034_/Q VGND VGND VPWR VPWR _5587_/A sky130_fd_sc_hd__dlygate4sd3_1
Xhold951 _7048_/Q VGND VGND VPWR VPWR hold951/X sky130_fd_sc_hd__dlygate4sd3_1
XFILLER_88_232 VGND VGND VPWR VPWR sky130_fd_sc_hd__fill_1
Xhold995 _7255_/Q VGND VGND VPWR VPWR hold995/X sky130_fd_sc_hd__dlygate4sd3_1
Xhold984 _7015_/Q VGND VGND VPWR VPWR _5626_/A sky130_fd_sc_hd__dlygate4sd3_1
X_6339_ _6463_/A VGND VGND VPWR VPWR _6339_/Y sky130_fd_sc_hd__inv_2
XFILLER_0_158 VGND VGND VPWR VPWR sky130_fd_sc_hd__decap_3
XFILLER_103_554 VGND VGND VPWR VPWR sky130_fd_sc_hd__decap_3
XFILLER_103_576 VGND VGND VPWR VPWR sky130_fd_sc_hd__fill_1
XFILLER_88_265 VGND VGND VPWR VPWR sky130_fd_sc_hd__fill_1
XFILLER_48_118 VGND VGND VPWR VPWR sky130_fd_sc_hd__fill_2
XFILLER_76_438 VGND VGND VPWR VPWR sky130_fd_sc_hd__decap_3
XFILLER_88_287 VGND VGND VPWR VPWR sky130_fd_sc_hd__decap_3
XFILLER_29_332 VGND VGND VPWR VPWR sky130_fd_sc_hd__decap_3
XFILLER_57_641 VGND VGND VPWR VPWR sky130_fd_sc_hd__decap_3
XFILLER_91_408 VGND VGND VPWR VPWR sky130_fd_sc_hd__fill_1
XFILLER_17_505 VGND VGND VPWR VPWR sky130_fd_sc_hd__decap_3
XFILLER_72_600 VGND VGND VPWR VPWR sky130_fd_sc_hd__fill_1
XFILLER_91_419 VGND VGND VPWR VPWR sky130_fd_sc_hd__decap_3
XFILLER_71_121 VGND VGND VPWR VPWR sky130_fd_sc_hd__decap_3
XFILLER_72_633 VGND VGND VPWR VPWR sky130_fd_sc_hd__decap_3
XTAP_TAPCELL_ROW_27_544 VGND VPWR sky130_fd_sc_hd__tapvpwrvgnd_1
XFILLER_71_143 VGND VGND VPWR VPWR sky130_fd_sc_hd__decap_3
XTAP_TAPCELL_ROW_55_864 VGND VPWR sky130_fd_sc_hd__tapvpwrvgnd_1
XFILLER_12_221 VGND VGND VPWR VPWR sky130_fd_sc_hd__decap_3
XFILLER_44_64 VGND VGND VPWR VPWR sky130_fd_sc_hd__decap_3
XFILLER_40_563 VGND VGND VPWR VPWR sky130_fd_sc_hd__decap_3
XFILLER_8_203 VGND VGND VPWR VPWR sky130_fd_sc_hd__decap_3
XFILLER_12_265 VGND VGND VPWR VPWR sky130_fd_sc_hd__fill_1
XFILLER_12_287 VGND VGND VPWR VPWR sky130_fd_sc_hd__decap_3
XFILLER_40_585 VGND VGND VPWR VPWR sky130_fd_sc_hd__decap_3
XFILLER_8_236 VGND VGND VPWR VPWR sky130_fd_sc_hd__decap_3
XFILLER_60_63 VGND VGND VPWR VPWR sky130_fd_sc_hd__fill_1
XFILLER_60_85 VGND VGND VPWR VPWR sky130_fd_sc_hd__decap_3
XFILLER_4_442 VGND VGND VPWR VPWR sky130_fd_sc_hd__decap_3
XFILLER_99_508 VGND VGND VPWR VPWR sky130_fd_sc_hd__decap_3
XFILLER_4_464 VGND VGND VPWR VPWR sky130_fd_sc_hd__decap_3
XFILLER_4_497 VGND VGND VPWR VPWR sky130_fd_sc_hd__decap_3
XFILLER_67_405 VGND VGND VPWR VPWR sky130_fd_sc_hd__decap_3
XFILLER_79_265 VGND VGND VPWR VPWR sky130_fd_sc_hd__decap_3
XFILLER_79_298 VGND VGND VPWR VPWR sky130_fd_sc_hd__fill_1
XFILLER_94_235 VGND VGND VPWR VPWR sky130_fd_sc_hd__decap_3
XFILLER_47_140 VGND VGND VPWR VPWR sky130_fd_sc_hd__decap_3
XFILLER_94_268 VGND VGND VPWR VPWR sky130_fd_sc_hd__fill_1
XFILLER_75_460 VGND VGND VPWR VPWR sky130_fd_sc_hd__decap_3
XTAP_TAPCELL_ROW_85_1214 VGND VPWR sky130_fd_sc_hd__tapvpwrvgnd_1
XFILLER_47_195 VGND VGND VPWR VPWR sky130_fd_sc_hd__decap_3
XFILLER_62_110 VGND VGND VPWR VPWR sky130_fd_sc_hd__decap_3
XFILLER_63_644 VGND VGND VPWR VPWR sky130_fd_sc_hd__decap_3
XFILLER_23_508 VGND VGND VPWR VPWR sky130_fd_sc_hd__fill_2
XFILLER_35_379 VGND VGND VPWR VPWR sky130_fd_sc_hd__decap_3
XFILLER_62_187 VGND VGND VPWR VPWR sky130_fd_sc_hd__decap_3
X_5710_ _7361_/Q hold928/X _5721_/S VGND VGND VPWR VPWR _6705_/D sky130_fd_sc_hd__mux2_2
X_6690_ clkload8/A _6690_/D VGND VGND VPWR VPWR _6690_/Q sky130_fd_sc_hd__dfxtp_2
X_5641_ _5641_/A VGND VGND VPWR VPWR _5641_/Y sky130_fd_sc_hd__inv_2
X_5572_ hold999/X _5647_/A _4961_/C VGND VGND VPWR VPWR _7045_/D sky130_fd_sc_hd__a21o_2
X_7311_ _7376_/CLK _7311_/D _6591_/Y VGND VGND VPWR VPWR _7311_/Q sky130_fd_sc_hd__dfrtp_2
XTAP_TAPCELL_ROW_96_1343 VGND VPWR sky130_fd_sc_hd__tapvpwrvgnd_1
XFILLER_7_291 VGND VGND VPWR VPWR sky130_fd_sc_hd__decap_3
X_7242_ _7276_/CLK _7242_/D _6522_/Y VGND VGND VPWR VPWR _7242_/Q sky130_fd_sc_hd__dfrtp_2
XFILLER_104_307 VGND VGND VPWR VPWR sky130_fd_sc_hd__fill_1
X_4454_ _4761_/B _4761_/C _4069_/Y _4762_/B VGND VGND VPWR VPWR _4454_/X sky130_fd_sc_hd__a211o_2
X_7173_ _7361_/CLK _7173_/D _6453_/Y VGND VGND VPWR VPWR _7173_/Q sky130_fd_sc_hd__dfrtp_2
X_4385_ _7337_/Q _3945_/S _4428_/B1 _7145_/Q VGND VGND VPWR VPWR _4385_/X sky130_fd_sc_hd__a22o_2
X_3405_ _3340_/A _5670_/A _3340_/C _4667_/B VGND VGND VPWR VPWR _3409_/D sky130_fd_sc_hd__o31a_2
XFILLER_105_26 VGND VGND VPWR VPWR sky130_fd_sc_hd__decap_3
XFILLER_85_213 VGND VGND VPWR VPWR sky130_fd_sc_hd__decap_3
XFILLER_39_641 VGND VGND VPWR VPWR sky130_fd_sc_hd__decap_3
XFILLER_73_408 VGND VGND VPWR VPWR sky130_fd_sc_hd__decap_3
XFILLER_85_268 VGND VGND VPWR VPWR sky130_fd_sc_hd__decap_3
X_5006_ _5006_/A1 _4626_/X _5003_/A _5033_/B2 VGND VGND VPWR VPWR _5006_/X sky130_fd_sc_hd__a22o_2
XFILLER_54_611 VGND VGND VPWR VPWR sky130_fd_sc_hd__decap_3
XFILLER_26_335 VGND VGND VPWR VPWR sky130_fd_sc_hd__decap_3
XFILLER_81_430 VGND VGND VPWR VPWR sky130_fd_sc_hd__decap_3
XFILLER_41_305 VGND VGND VPWR VPWR sky130_fd_sc_hd__fill_2
XFILLER_53_165 VGND VGND VPWR VPWR sky130_fd_sc_hd__decap_3
X_6957_ _6963_/CLK _6957_/D VGND VGND VPWR VPWR _6957_/Q sky130_fd_sc_hd__dfxtp_2
XFILLER_53_187 VGND VGND VPWR VPWR sky130_fd_sc_hd__decap_3
XFILLER_81_485 VGND VGND VPWR VPWR sky130_fd_sc_hd__decap_3
XTAP_TAPCELL_ROW_52_834 VGND VPWR sky130_fd_sc_hd__tapvpwrvgnd_1
XTAP_TAPCELL_ROW_24_514 VGND VPWR sky130_fd_sc_hd__tapvpwrvgnd_1
XFILLER_22_530 VGND VGND VPWR VPWR sky130_fd_sc_hd__fill_2
X_6888_ clkload8/A _6888_/D VGND VGND VPWR VPWR _6888_/Q sky130_fd_sc_hd__dfxtp_2
XFILLER_108_635 VGND VGND VPWR VPWR sky130_fd_sc_hd__fill_1
XFILLER_30_22 VGND VGND VPWR VPWR sky130_fd_sc_hd__fill_2
XFILLER_5_228 VGND VGND VPWR VPWR sky130_fd_sc_hd__decap_3
XFILLER_107_178 VGND VGND VPWR VPWR sky130_fd_sc_hd__fill_1
Xhold770 _6774_/Q VGND VGND VPWR VPWR _6774_/D sky130_fd_sc_hd__dlygate4sd3_1
Xhold781 _6738_/Q VGND VGND VPWR VPWR _6738_/D sky130_fd_sc_hd__dlygate4sd3_1
XFILLER_103_340 VGND VGND VPWR VPWR sky130_fd_sc_hd__decap_3
Xhold792 _6950_/Q VGND VGND VPWR VPWR _6950_/D sky130_fd_sc_hd__dlygate4sd3_1
XFILLER_103_373 VGND VGND VPWR VPWR sky130_fd_sc_hd__decap_3
XFILLER_39_53 VGND VGND VPWR VPWR sky130_fd_sc_hd__decap_3
XFILLER_39_75 VGND VGND VPWR VPWR sky130_fd_sc_hd__fill_1
XFILLER_76_235 VGND VGND VPWR VPWR sky130_fd_sc_hd__decap_3
XFILLER_76_268 VGND VGND VPWR VPWR sky130_fd_sc_hd__fill_1
XFILLER_17_313 VGND VGND VPWR VPWR sky130_fd_sc_hd__fill_2
XFILLER_29_151 VGND VGND VPWR VPWR sky130_fd_sc_hd__decap_3
XFILLER_64_419 VGND VGND VPWR VPWR sky130_fd_sc_hd__fill_1
XTAP_TAPCELL_ROW_4_283 VGND VPWR sky130_fd_sc_hd__tapvpwrvgnd_1
XFILLER_17_324 VGND VGND VPWR VPWR sky130_fd_sc_hd__decap_3
XFILLER_29_184 VGND VGND VPWR VPWR sky130_fd_sc_hd__decap_3
XFILLER_45_644 VGND VGND VPWR VPWR sky130_fd_sc_hd__decap_3
XFILLER_72_430 VGND VGND VPWR VPWR sky130_fd_sc_hd__fill_2
XFILLER_91_249 VGND VGND VPWR VPWR sky130_fd_sc_hd__decap_3
XFILLER_44_132 VGND VGND VPWR VPWR sky130_fd_sc_hd__decap_3
XFILLER_44_165 VGND VGND VPWR VPWR sky130_fd_sc_hd__decap_3
XFILLER_60_603 VGND VGND VPWR VPWR sky130_fd_sc_hd__decap_3
XFILLER_32_338 VGND VGND VPWR VPWR sky130_fd_sc_hd__decap_3
XFILLER_60_636 VGND VGND VPWR VPWR sky130_fd_sc_hd__decap_3
XFILLER_13_530 VGND VGND VPWR VPWR sky130_fd_sc_hd__decap_3
XFILLER_13_541 VGND VGND VPWR VPWR sky130_fd_sc_hd__decap_3
XFILLER_13_585 VGND VGND VPWR VPWR sky130_fd_sc_hd__decap_3
XFILLER_40_371 VGND VGND VPWR VPWR sky130_fd_sc_hd__fill_1
XTAP_TAPCELL_ROW_80_1155 VGND VPWR sky130_fd_sc_hd__tapvpwrvgnd_1
XFILLER_9_567 VGND VGND VPWR VPWR sky130_fd_sc_hd__decap_3
XFILLER_9_556 VGND VGND VPWR VPWR sky130_fd_sc_hd__decap_3
XFILLER_4_272 VGND VGND VPWR VPWR sky130_fd_sc_hd__decap_3
XFILLER_4_294 VGND VGND VPWR VPWR sky130_fd_sc_hd__decap_3
X_4170_ _4203_/A _4203_/B _4202_/A VGND VGND VPWR VPWR _4938_/B sky130_fd_sc_hd__and3_2
XFILLER_67_202 VGND VGND VPWR VPWR sky130_fd_sc_hd__fill_1
XTAP_TAPCELL_ROW_91_1284 VGND VPWR sky130_fd_sc_hd__tapvpwrvgnd_1
XFILLER_36_611 VGND VGND VPWR VPWR sky130_fd_sc_hd__decap_3
XFILLER_82_216 VGND VGND VPWR VPWR sky130_fd_sc_hd__decap_3
XFILLER_35_154 VGND VGND VPWR VPWR sky130_fd_sc_hd__decap_3
XFILLER_51_614 VGND VGND VPWR VPWR sky130_fd_sc_hd__fill_2
XFILLER_63_452 VGND VGND VPWR VPWR sky130_fd_sc_hd__fill_2
Xplace430 _4348_/A2 VGND VGND VPWR VPWR _4261_/B1 sky130_fd_sc_hd__buf_2
X_6811_ _6976_/CLK _6811_/D VGND VGND VPWR VPWR _6811_/Q sky130_fd_sc_hd__dfxtp_2
XFILLER_50_124 VGND VGND VPWR VPWR sky130_fd_sc_hd__decap_3
XFILLER_51_647 VGND VGND VPWR VPWR sky130_fd_sc_hd__fill_1
Xplace441 _4414_/A2 VGND VGND VPWR VPWR _4433_/B sky130_fd_sc_hd__buf_2
Xplace452 _6981_/Q VGND VGND VPWR VPWR _3371_/A sky130_fd_sc_hd__buf_2
X_6742_ clkload3/A _6742_/D VGND VGND VPWR VPWR _6742_/Q sky130_fd_sc_hd__dfxtp_2
X_3954_ _7363_/Q _7331_/Q _3956_/S VGND VGND VPWR VPWR _7363_/D sky130_fd_sc_hd__mux2_2
X_6673_ _6680_/A VGND VGND VPWR VPWR _6673_/Y sky130_fd_sc_hd__inv_2
X_3885_ _3746_/X _3882_/X _3884_/X _3725_/X VGND VGND VPWR VPWR _3885_/X sky130_fd_sc_hd__a22o_2
XFILLER_31_393 VGND VGND VPWR VPWR sky130_fd_sc_hd__decap_3
X_5624_ _5624_/A _5628_/B VGND VGND VPWR VPWR _7016_/D sky130_fd_sc_hd__or2_2
XTAP_TAPCELL_ROW_100_1380 VGND VPWR sky130_fd_sc_hd__tapvpwrvgnd_1
XFILLER_105_638 VGND VGND VPWR VPWR sky130_fd_sc_hd__fill_2
X_7225_ _7357_/CLK _7225_/D _6505_/Y VGND VGND VPWR VPWR _7225_/Q sky130_fd_sc_hd__dfrtp_2
X_4437_ _7022_/Q _4437_/A2 _4437_/B1 _7399_/Q _4436_/X VGND VGND VPWR VPWR _4437_/X
+ sky130_fd_sc_hd__a221o_2
XFILLER_104_159 VGND VGND VPWR VPWR sky130_fd_sc_hd__decap_3
X_7156_ _7380_/CLK _7156_/D _6436_/Y VGND VGND VPWR VPWR _7156_/Q sky130_fd_sc_hd__dfrtp_2
XFILLER_58_224 VGND VGND VPWR VPWR sky130_fd_sc_hd__decap_3
XFILLER_76_29 VGND VGND VPWR VPWR sky130_fd_sc_hd__decap_3
XFILLER_86_511 VGND VGND VPWR VPWR sky130_fd_sc_hd__fill_2
XFILLER_86_522 VGND VGND VPWR VPWR sky130_fd_sc_hd__fill_1
X_4368_ _5073_/A _4366_/X _5054_/A VGND VGND VPWR VPWR _4369_/B sky130_fd_sc_hd__a21oi_2
XFILLER_100_321 VGND VGND VPWR VPWR sky130_fd_sc_hd__decap_3
XFILLER_100_343 VGND VGND VPWR VPWR sky130_fd_sc_hd__decap_3
X_7087_ _7348_/CLK _7087_/D _6367_/Y VGND VGND VPWR VPWR _7087_/Q sky130_fd_sc_hd__dfstp_2
X_4299_ _3620_/A _4292_/X _4298_/X VGND VGND VPWR VPWR _5100_/B sky130_fd_sc_hd__a21o_2
X_3319_ _3378_/A _5646_/A _5647_/A _5647_/B VGND VGND VPWR VPWR _3319_/X sky130_fd_sc_hd__and4b_4
XFILLER_100_365 VGND VGND VPWR VPWR sky130_fd_sc_hd__decap_3
XFILLER_27_600 VGND VGND VPWR VPWR sky130_fd_sc_hd__decap_3
XFILLER_73_216 VGND VGND VPWR VPWR sky130_fd_sc_hd__decap_3
XFILLER_27_644 VGND VGND VPWR VPWR sky130_fd_sc_hd__decap_3
XFILLER_54_430 VGND VGND VPWR VPWR sky130_fd_sc_hd__decap_3
XFILLER_66_290 VGND VGND VPWR VPWR sky130_fd_sc_hd__decap_3
XTAP_TAPCELL_ROW_1_242 VGND VPWR sky130_fd_sc_hd__tapvpwrvgnd_1
XFILLER_25_11 VGND VGND VPWR VPWR sky130_fd_sc_hd__decap_3
XFILLER_25_22 VGND VGND VPWR VPWR sky130_fd_sc_hd__fill_1
XFILLER_41_113 VGND VGND VPWR VPWR sky130_fd_sc_hd__decap_3
XFILLER_42_636 VGND VGND VPWR VPWR sky130_fd_sc_hd__decap_3
XTAP_TAPCELL_ROW_65_981 VGND VPWR sky130_fd_sc_hd__tapvpwrvgnd_1
XTAP_TAPCELL_ROW_37_661 VGND VPWR sky130_fd_sc_hd__tapvpwrvgnd_1
XFILLER_10_500 VGND VGND VPWR VPWR sky130_fd_sc_hd__decap_3
XFILLER_10_533 VGND VGND VPWR VPWR sky130_fd_sc_hd__fill_1
XFILLER_10_577 VGND VGND VPWR VPWR sky130_fd_sc_hd__decap_3
XFILLER_41_54 VGND VGND VPWR VPWR sky130_fd_sc_hd__fill_2
XFILLER_108_421 VGND VGND VPWR VPWR sky130_fd_sc_hd__decap_3
XFILLER_108_443 VGND VGND VPWR VPWR sky130_fd_sc_hd__decap_3
XFILLER_41_76 VGND VGND VPWR VPWR sky130_fd_sc_hd__fill_2
XTAP_TAPCELL_ROW_9_342 VGND VPWR sky130_fd_sc_hd__tapvpwrvgnd_1
XFILLER_1_220 VGND VGND VPWR VPWR sky130_fd_sc_hd__decap_3
XFILLER_1_264 VGND VGND VPWR VPWR sky130_fd_sc_hd__decap_3
XFILLER_2_15 VGND VGND VPWR VPWR sky130_fd_sc_hd__decap_3
XFILLER_49_202 VGND VGND VPWR VPWR sky130_fd_sc_hd__decap_3
XFILLER_1_297 VGND VGND VPWR VPWR sky130_fd_sc_hd__decap_3
XFILLER_77_544 VGND VGND VPWR VPWR sky130_fd_sc_hd__decap_3
XFILLER_89_393 VGND VGND VPWR VPWR sky130_fd_sc_hd__fill_2
XFILLER_106_91 VGND VGND VPWR VPWR sky130_fd_sc_hd__decap_3
XFILLER_77_599 VGND VGND VPWR VPWR sky130_fd_sc_hd__fill_2
XFILLER_18_622 VGND VGND VPWR VPWR sky130_fd_sc_hd__decap_3
XFILLER_57_290 VGND VGND VPWR VPWR sky130_fd_sc_hd__decap_3
XFILLER_64_238 VGND VGND VPWR VPWR sky130_fd_sc_hd__fill_1
XFILLER_92_536 VGND VGND VPWR VPWR sky130_fd_sc_hd__decap_3
XFILLER_92_547 VGND VGND VPWR VPWR sky130_fd_sc_hd__decap_3
XTAP_TAPCELL_ROW_69_1028 VGND VPWR sky130_fd_sc_hd__tapvpwrvgnd_1
XFILLER_17_165 VGND VGND VPWR VPWR sky130_fd_sc_hd__decap_3
XFILLER_32_102 VGND VGND VPWR VPWR sky130_fd_sc_hd__decap_3
XFILLER_17_198 VGND VGND VPWR VPWR sky130_fd_sc_hd__decap_3
XFILLER_33_647 VGND VGND VPWR VPWR sky130_fd_sc_hd__fill_1
XFILLER_60_455 VGND VGND VPWR VPWR sky130_fd_sc_hd__fill_1
XFILLER_82_61 VGND VGND VPWR VPWR sky130_fd_sc_hd__decap_3
XFILLER_60_477 VGND VGND VPWR VPWR sky130_fd_sc_hd__fill_2
XFILLER_60_488 VGND VGND VPWR VPWR sky130_fd_sc_hd__fill_1
XFILLER_13_393 VGND VGND VPWR VPWR sky130_fd_sc_hd__decap_3
XFILLER_9_331 VGND VGND VPWR VPWR sky130_fd_sc_hd__decap_3
XFILLER_40_190 VGND VGND VPWR VPWR sky130_fd_sc_hd__decap_3
X_3670_ _3682_/A _3669_/X _5104_/A VGND VGND VPWR VPWR _3670_/X sky130_fd_sc_hd__a21o_2
XFILLER_9_386 VGND VGND VPWR VPWR sky130_fd_sc_hd__decap_3
XFILLER_9_364 VGND VGND VPWR VPWR sky130_fd_sc_hd__decap_3
XFILLER_56_3 VGND VGND VPWR VPWR sky130_fd_sc_hd__decap_3
X_5340_ _5340_/A0 _5079_/X _5358_/S VGND VGND VPWR VPWR _7161_/D sky130_fd_sc_hd__mux2_2
XTAP_TAPCELL_ROW_93_1302 VGND VPWR sky130_fd_sc_hd__tapvpwrvgnd_1
XFILLER_5_570 VGND VGND VPWR VPWR sky130_fd_sc_hd__decap_3
XFILLER_99_113 VGND VGND VPWR VPWR sky130_fd_sc_hd__fill_2
XFILLER_87_308 VGND VGND VPWR VPWR sky130_fd_sc_hd__decap_3
X_7010_ _7083_/CLK _7010_/D _6290_/Y VGND VGND VPWR VPWR _7010_/Q sky130_fd_sc_hd__dfrtp_2
X_4222_ _7356_/Q _4272_/B _4221_/X VGND VGND VPWR VPWR _4222_/X sky130_fd_sc_hd__a21o_2
XFILLER_99_146 VGND VGND VPWR VPWR sky130_fd_sc_hd__decap_3
XFILLER_68_533 VGND VGND VPWR VPWR sky130_fd_sc_hd__decap_3
XFILLER_68_566 VGND VGND VPWR VPWR sky130_fd_sc_hd__decap_3
X_4153_ _7298_/Q _4352_/A2 _4436_/B1 _7170_/Q _4152_/X VGND VGND VPWR VPWR _4153_/X
+ sky130_fd_sc_hd__a221o_2
XFILLER_28_408 VGND VGND VPWR VPWR sky130_fd_sc_hd__fill_1
XFILLER_28_419 VGND VGND VPWR VPWR sky130_fd_sc_hd__fill_1
XFILLER_55_205 VGND VGND VPWR VPWR sky130_fd_sc_hd__decap_3
X_4084_ _7302_/Q _4478_/S _4083_/X _4429_/C1 VGND VGND VPWR VPWR _4084_/X sky130_fd_sc_hd__a211o_2
XFILLER_102_27 VGND VGND VPWR VPWR sky130_fd_sc_hd__fill_1
XFILLER_36_430 VGND VGND VPWR VPWR sky130_fd_sc_hd__decap_3
XFILLER_36_452 VGND VGND VPWR VPWR sky130_fd_sc_hd__decap_3
XFILLER_24_625 VGND VGND VPWR VPWR sky130_fd_sc_hd__decap_3
XFILLER_51_422 VGND VGND VPWR VPWR sky130_fd_sc_hd__fill_1
XFILLER_63_260 VGND VGND VPWR VPWR sky130_fd_sc_hd__decap_3
XFILLER_63_271 VGND VGND VPWR VPWR sky130_fd_sc_hd__decap_3
XFILLER_23_135 VGND VGND VPWR VPWR sky130_fd_sc_hd__fill_2
Xplace282 _3661_/X VGND VGND VPWR VPWR _3926_/A2 sky130_fd_sc_hd__buf_2
Xplace271 _3665_/X VGND VGND VPWR VPWR _3911_/B1 sky130_fd_sc_hd__buf_2
X_4986_ _5003_/A _5003_/B _4626_/X VGND VGND VPWR VPWR _4987_/B sky130_fd_sc_hd__a21oi_2
XTAP_TAPCELL_ROW_62_951 VGND VPWR sky130_fd_sc_hd__tapvpwrvgnd_1
XTAP_TAPCELL_ROW_34_631 VGND VPWR sky130_fd_sc_hd__tapvpwrvgnd_1
XTAP_TAPCELL_ROW_34_620 VGND VPWR sky130_fd_sc_hd__tapvpwrvgnd_1
XFILLER_11_308 VGND VGND VPWR VPWR sky130_fd_sc_hd__decap_3
XFILLER_51_477 VGND VGND VPWR VPWR sky130_fd_sc_hd__decap_3
Xplace293 _3879_/B1 VGND VGND VPWR VPWR _3883_/A2 sky130_fd_sc_hd__buf_2
X_6725_ clkload5/A _6725_/D VGND VGND VPWR VPWR _6725_/Q sky130_fd_sc_hd__dfxtp_2
X_3937_ _7371_/Q _4480_/A0 _3939_/S VGND VGND VPWR VPWR _7371_/D sky130_fd_sc_hd__mux2_2
XFILLER_31_190 VGND VGND VPWR VPWR sky130_fd_sc_hd__decap_3
X_6656_ _6662_/A VGND VGND VPWR VPWR _6656_/Y sky130_fd_sc_hd__inv_2
X_3868_ hold938/X _3423_/A _3867_/X VGND VGND VPWR VPWR _7384_/D sky130_fd_sc_hd__a21o_2
XFILLER_11_24 VGND VGND VPWR VPWR sky130_fd_sc_hd__decap_3
X_6587_ _6619_/A VGND VGND VPWR VPWR _6587_/Y sky130_fd_sc_hd__inv_2
X_5607_ _5607_/A _5634_/B VGND VGND VPWR VPWR _7024_/D sky130_fd_sc_hd__and2_2
X_3799_ _6909_/Q _3888_/A2 _3893_/B1 _6853_/Q VGND VGND VPWR VPWR _3799_/X sky130_fd_sc_hd__a22o_2
XFILLER_105_402 VGND VGND VPWR VPWR sky130_fd_sc_hd__decap_3
XFILLER_11_57 VGND VGND VPWR VPWR sky130_fd_sc_hd__decap_3
XFILLER_105_479 VGND VGND VPWR VPWR sky130_fd_sc_hd__decap_3
X_7208_ _7363_/CLK _7208_/D _6488_/Y VGND VGND VPWR VPWR _7208_/Q sky130_fd_sc_hd__dfrtp_2
XTAP_TAPCELL_ROW_6_301 VGND VPWR sky130_fd_sc_hd__tapvpwrvgnd_1
XFILLER_78_319 VGND VGND VPWR VPWR sky130_fd_sc_hd__decap_3
XFILLER_101_641 VGND VGND VPWR VPWR sky130_fd_sc_hd__decap_3
X_7139_ _7362_/CLK _7139_/D _6419_/Y VGND VGND VPWR VPWR _7139_/Q sky130_fd_sc_hd__dfrtp_2
XFILLER_36_21 VGND VGND VPWR VPWR sky130_fd_sc_hd__decap_3
XFILLER_46_216 VGND VGND VPWR VPWR sky130_fd_sc_hd__decap_3
XFILLER_15_603 VGND VGND VPWR VPWR sky130_fd_sc_hd__decap_3
XFILLER_36_32 VGND VGND VPWR VPWR sky130_fd_sc_hd__fill_1
XFILLER_39_290 VGND VGND VPWR VPWR sky130_fd_sc_hd__fill_2
XFILLER_61_208 VGND VGND VPWR VPWR sky130_fd_sc_hd__decap_3
XFILLER_42_400 VGND VGND VPWR VPWR sky130_fd_sc_hd__decap_3
XFILLER_82_580 VGND VGND VPWR VPWR sky130_fd_sc_hd__fill_1
XFILLER_14_124 VGND VGND VPWR VPWR sky130_fd_sc_hd__decap_3
XFILLER_15_647 VGND VGND VPWR VPWR sky130_fd_sc_hd__fill_1
XFILLER_54_282 VGND VGND VPWR VPWR sky130_fd_sc_hd__decap_3
XFILLER_30_628 VGND VGND VPWR VPWR sky130_fd_sc_hd__decap_3
XFILLER_52_97 VGND VGND VPWR VPWR sky130_fd_sc_hd__fill_1
XTAP_TAPCELL_ROW_12_369 VGND VPWR sky130_fd_sc_hd__tapvpwrvgnd_1
XFILLER_10_374 VGND VGND VPWR VPWR sky130_fd_sc_hd__decap_3
XTAP_TAPCELL_ROW_40_689 VGND VPWR sky130_fd_sc_hd__tapvpwrvgnd_1
XFILLER_108_284 VGND VGND VPWR VPWR sky130_fd_sc_hd__fill_1
XFILLER_2_551 VGND VGND VPWR VPWR sky130_fd_sc_hd__decap_3
XFILLER_97_606 VGND VGND VPWR VPWR sky130_fd_sc_hd__decap_3
XFILLER_2_584 VGND VGND VPWR VPWR sky130_fd_sc_hd__decap_3
XTAP_TAPCELL_ROW_75_1098 VGND VPWR sky130_fd_sc_hd__tapvpwrvgnd_1
XFILLER_97_628 VGND VGND VPWR VPWR sky130_fd_sc_hd__decap_3
XFILLER_2_595 VGND VGND VPWR VPWR sky130_fd_sc_hd__decap_3
XFILLER_89_190 VGND VGND VPWR VPWR sky130_fd_sc_hd__decap_3
XFILLER_96_149 VGND VGND VPWR VPWR sky130_fd_sc_hd__decap_3
XFILLER_96_138 VGND VGND VPWR VPWR sky130_fd_sc_hd__fill_2
XFILLER_65_514 VGND VGND VPWR VPWR sky130_fd_sc_hd__decap_3
XFILLER_77_352 VGND VGND VPWR VPWR sky130_fd_sc_hd__decap_3
XFILLER_77_363 VGND VGND VPWR VPWR sky130_fd_sc_hd__decap_3
XFILLER_18_441 VGND VGND VPWR VPWR sky130_fd_sc_hd__fill_1
XFILLER_65_558 VGND VGND VPWR VPWR sky130_fd_sc_hd__fill_2
XFILLER_92_344 VGND VGND VPWR VPWR sky130_fd_sc_hd__decap_3
XFILLER_18_485 VGND VGND VPWR VPWR sky130_fd_sc_hd__decap_3
XFILLER_52_219 VGND VGND VPWR VPWR sky130_fd_sc_hd__decap_3
XFILLER_80_539 VGND VGND VPWR VPWR sky130_fd_sc_hd__decap_3
XFILLER_92_377 VGND VGND VPWR VPWR sky130_fd_sc_hd__decap_3
XFILLER_93_93 VGND VGND VPWR VPWR sky130_fd_sc_hd__decap_3
XTAP_TAPCELL_ROW_48_789 VGND VPWR sky130_fd_sc_hd__tapvpwrvgnd_1
XFILLER_45_293 VGND VGND VPWR VPWR sky130_fd_sc_hd__fill_1
X_4840_ _4903_/B _4903_/C _4903_/A VGND VGND VPWR VPWR _4888_/B sky130_fd_sc_hd__a21oi_2
XFILLER_21_617 VGND VGND VPWR VPWR sky130_fd_sc_hd__decap_3
XFILLER_33_488 VGND VGND VPWR VPWR sky130_fd_sc_hd__decap_3
XFILLER_60_274 VGND VGND VPWR VPWR sky130_fd_sc_hd__decap_3
X_6510_ _6609_/A VGND VGND VPWR VPWR _6510_/Y sky130_fd_sc_hd__inv_2
X_4771_ _5061_/S _7005_/D _4760_/Y _4770_/X VGND VGND VPWR VPWR _4771_/X sky130_fd_sc_hd__o211a_2
XFILLER_9_161 VGND VGND VPWR VPWR sky130_fd_sc_hd__decap_3
X_6441_ _6638_/A VGND VGND VPWR VPWR _6441_/Y sky130_fd_sc_hd__inv_2
XFILLER_9_172 VGND VGND VPWR VPWR sky130_fd_sc_hd__decap_3
X_6372_ _6566_/A VGND VGND VPWR VPWR _6372_/Y sky130_fd_sc_hd__inv_2
X_5323_ _5323_/A0 _4945_/X _5333_/S VGND VGND VPWR VPWR _7169_/D sky130_fd_sc_hd__mux2_2
X_3584_ _3424_/S _3583_/X _5648_/B VGND VGND VPWR VPWR _3586_/D sky130_fd_sc_hd__a21oi_2
XFILLER_102_416 VGND VGND VPWR VPWR sky130_fd_sc_hd__decap_3
XFILLER_87_149 VGND VGND VPWR VPWR sky130_fd_sc_hd__decap_3
X_4205_ _4205_/A _4205_/B _4205_/C VGND VGND VPWR VPWR _4205_/X sky130_fd_sc_hd__and3_2
XFILLER_68_352 VGND VGND VPWR VPWR sky130_fd_sc_hd__decap_3
X_4136_ _7235_/Q _4414_/A2 _4865_/S _7299_/Q _4135_/X VGND VGND VPWR VPWR _4136_/X
+ sky130_fd_sc_hd__a221o_2
XFILLER_28_216 VGND VGND VPWR VPWR sky130_fd_sc_hd__decap_3
XFILLER_56_536 VGND VGND VPWR VPWR sky130_fd_sc_hd__decap_3
XFILLER_83_333 VGND VGND VPWR VPWR sky130_fd_sc_hd__decap_3
XFILLER_95_193 VGND VGND VPWR VPWR sky130_fd_sc_hd__fill_2
XFILLER_83_355 VGND VGND VPWR VPWR sky130_fd_sc_hd__decap_3
X_4067_ _4068_/A _4082_/A VGND VGND VPWR VPWR _4744_/B sky130_fd_sc_hd__and2_2
XFILLER_83_388 VGND VGND VPWR VPWR sky130_fd_sc_hd__decap_3
XFILLER_12_628 VGND VGND VPWR VPWR sky130_fd_sc_hd__decap_3
XFILLER_24_477 VGND VGND VPWR VPWR sky130_fd_sc_hd__decap_3
XFILLER_11_116 VGND VGND VPWR VPWR sky130_fd_sc_hd__fill_1
XFILLER_11_138 VGND VGND VPWR VPWR sky130_fd_sc_hd__decap_3
XFILLER_51_296 VGND VGND VPWR VPWR sky130_fd_sc_hd__decap_3
X_4969_ _4968_/Y _4969_/B _4969_/C VGND VGND VPWR VPWR _4969_/X sky130_fd_sc_hd__and3b_2
XFILLER_22_23 VGND VGND VPWR VPWR sky130_fd_sc_hd__decap_3
X_6708_ _7071_/CLK _6708_/D VGND VGND VPWR VPWR _6708_/Q sky130_fd_sc_hd__dfxtp_2
X_6639_ _6640_/A VGND VGND VPWR VPWR _6639_/Y sky130_fd_sc_hd__inv_2
XFILLER_105_221 VGND VGND VPWR VPWR sky130_fd_sc_hd__decap_3
XFILLER_3_337 VGND VGND VPWR VPWR sky130_fd_sc_hd__decap_3
XFILLER_105_287 VGND VGND VPWR VPWR sky130_fd_sc_hd__decap_3
XFILLER_79_617 VGND VGND VPWR VPWR sky130_fd_sc_hd__fill_1
XFILLER_79_639 VGND VGND VPWR VPWR sky130_fd_sc_hd__decap_3
Xoutput480 _3634_/Y VGND VGND VPWR VPWR alu_result_out[2] sky130_fd_sc_hd__clkdlybuf4s25_1
XFILLER_59_330 VGND VGND VPWR VPWR sky130_fd_sc_hd__fill_1
Xoutput491 _5647_/Y VGND VGND VPWR VPWR instruction_out[11] sky130_fd_sc_hd__clkdlybuf4s25_1
XFILLER_93_108 VGND VGND VPWR VPWR sky130_fd_sc_hd__decap_3
XFILLER_93_119 VGND VGND VPWR VPWR sky130_fd_sc_hd__fill_1
XFILLER_101_482 VGND VGND VPWR VPWR sky130_fd_sc_hd__decap_3
XFILLER_101_493 VGND VGND VPWR VPWR sky130_fd_sc_hd__decap_3
XFILLER_47_547 VGND VGND VPWR VPWR sky130_fd_sc_hd__decap_3
XFILLER_74_300 VGND VGND VPWR VPWR sky130_fd_sc_hd__decap_3
XFILLER_86_182 VGND VGND VPWR VPWR sky130_fd_sc_hd__decap_3
XFILLER_74_355 VGND VGND VPWR VPWR sky130_fd_sc_hd__decap_3
XFILLER_27_271 VGND VGND VPWR VPWR sky130_fd_sc_hd__decap_3
XFILLER_62_528 VGND VGND VPWR VPWR sky130_fd_sc_hd__decap_3
XFILLER_74_377 VGND VGND VPWR VPWR sky130_fd_sc_hd__decap_3
XFILLER_74_388 VGND VGND VPWR VPWR sky130_fd_sc_hd__fill_2
XFILLER_74_399 VGND VGND VPWR VPWR sky130_fd_sc_hd__fill_1
XTAP_TAPCELL_ROW_17_428 VGND VPWR sky130_fd_sc_hd__tapvpwrvgnd_1
XFILLER_103_70 VGND VGND VPWR VPWR sky130_fd_sc_hd__decap_3
XFILLER_103_92 VGND VGND VPWR VPWR sky130_fd_sc_hd__decap_3
XFILLER_15_433 VGND VGND VPWR VPWR sky130_fd_sc_hd__decap_3
XFILLER_42_230 VGND VGND VPWR VPWR sky130_fd_sc_hd__decap_3
XFILLER_55_591 VGND VGND VPWR VPWR sky130_fd_sc_hd__fill_1
XTAP_TAPCELL_ROW_45_748 VGND VPWR sky130_fd_sc_hd__tapvpwrvgnd_1
XFILLER_15_455 VGND VGND VPWR VPWR sky130_fd_sc_hd__decap_3
XFILLER_70_572 VGND VGND VPWR VPWR sky130_fd_sc_hd__decap_3
XFILLER_10_160 VGND VGND VPWR VPWR sky130_fd_sc_hd__decap_3
XFILLER_7_632 VGND VGND VPWR VPWR sky130_fd_sc_hd__decap_3
XFILLER_10_171 VGND VGND VPWR VPWR sky130_fd_sc_hd__decap_3
XFILLER_10_193 VGND VGND VPWR VPWR sky130_fd_sc_hd__decap_3
XTAP_TAPCELL_ROW_77_1116 VGND VPWR sky130_fd_sc_hd__tapvpwrvgnd_1
XFILLER_6_175 VGND VGND VPWR VPWR sky130_fd_sc_hd__decap_3
XFILLER_40_6 VGND VGND VPWR VPWR sky130_fd_sc_hd__fill_1
XFILLER_6_197 VGND VGND VPWR VPWR sky130_fd_sc_hd__decap_3
XFILLER_69_105 VGND VGND VPWR VPWR sky130_fd_sc_hd__decap_3
XFILLER_88_82 VGND VGND VPWR VPWR sky130_fd_sc_hd__fill_2
XFILLER_97_414 VGND VGND VPWR VPWR sky130_fd_sc_hd__decap_3
XFILLER_2_381 VGND VGND VPWR VPWR sky130_fd_sc_hd__fill_1
XFILLER_97_458 VGND VGND VPWR VPWR sky130_fd_sc_hd__fill_1
XFILLER_38_525 VGND VGND VPWR VPWR sky130_fd_sc_hd__decap_3
XFILLER_93_620 VGND VGND VPWR VPWR sky130_fd_sc_hd__decap_3
XFILLER_38_558 VGND VGND VPWR VPWR sky130_fd_sc_hd__decap_3
XFILLER_65_366 VGND VGND VPWR VPWR sky130_fd_sc_hd__decap_3
XFILLER_77_193 VGND VGND VPWR VPWR sky130_fd_sc_hd__decap_3
XFILLER_92_141 VGND VGND VPWR VPWR sky130_fd_sc_hd__decap_3
X_6990_ _7392_/CLK _6990_/D _6270_/Y VGND VGND VPWR VPWR _6990_/Q sky130_fd_sc_hd__dfrtp_2
XTAP_TAPCELL_ROW_88_1245 VGND VPWR sky130_fd_sc_hd__tapvpwrvgnd_1
XFILLER_25_208 VGND VGND VPWR VPWR sky130_fd_sc_hd__decap_3
XFILLER_65_388 VGND VGND VPWR VPWR sky130_fd_sc_hd__decap_3
XFILLER_80_303 VGND VGND VPWR VPWR sky130_fd_sc_hd__decap_3
XFILLER_92_185 VGND VGND VPWR VPWR sky130_fd_sc_hd__decap_3
XFILLER_18_293 VGND VGND VPWR VPWR sky130_fd_sc_hd__fill_2
XFILLER_80_336 VGND VGND VPWR VPWR sky130_fd_sc_hd__decap_3
XFILLER_80_358 VGND VGND VPWR VPWR sky130_fd_sc_hd__decap_3
XFILLER_61_572 VGND VGND VPWR VPWR sky130_fd_sc_hd__decap_3
X_4823_ _4823_/A0 _4822_/X _4865_/S VGND VGND VPWR VPWR _7272_/D sky130_fd_sc_hd__mux2_2
XFILLER_21_458 VGND VGND VPWR VPWR sky130_fd_sc_hd__decap_3
X_3705_ _7400_/Q _3704_/X _4799_/A VGND VGND VPWR VPWR _7400_/D sky130_fd_sc_hd__mux2_2
XFILLER_107_508 VGND VGND VPWR VPWR sky130_fd_sc_hd__decap_3
X_4685_ _6996_/Q _4668_/X _4928_/B _4684_/X VGND VGND VPWR VPWR _4858_/B sky130_fd_sc_hd__a31o_2
XTAP_TAPCELL_ROW_99_1374 VGND VPWR sky130_fd_sc_hd__tapvpwrvgnd_1
X_6424_ _6645_/A VGND VGND VPWR VPWR _6424_/Y sky130_fd_sc_hd__inv_2
X_3636_ _3636_/A _3636_/B VGND VGND VPWR VPWR _3636_/Y sky130_fd_sc_hd__nor2_2
X_6355_ _6364_/A VGND VGND VPWR VPWR _6355_/Y sky130_fd_sc_hd__inv_2
X_3567_ _7221_/Q _4307_/A2 _3488_/B _7034_/Q _3566_/X VGND VGND VPWR VPWR _3567_/X
+ sky130_fd_sc_hd__a221o_2
XFILLER_88_414 VGND VGND VPWR VPWR sky130_fd_sc_hd__decap_3
X_6286_ _6397_/A VGND VGND VPWR VPWR _6286_/Y sky130_fd_sc_hd__inv_2
X_5306_ _5306_/A0 _4806_/X _5310_/S VGND VGND VPWR VPWR _7177_/D sky130_fd_sc_hd__mux2_2
XFILLER_102_235 VGND VGND VPWR VPWR sky130_fd_sc_hd__decap_3
X_3498_ _3423_/A _3442_/B _3449_/B VGND VGND VPWR VPWR _5152_/B sky130_fd_sc_hd__a21oi_2
XFILLER_75_108 VGND VGND VPWR VPWR sky130_fd_sc_hd__decap_3
XFILLER_29_514 VGND VGND VPWR VPWR sky130_fd_sc_hd__decap_3
XFILLER_29_536 VGND VGND VPWR VPWR sky130_fd_sc_hd__decap_3
XFILLER_68_171 VGND VGND VPWR VPWR sky130_fd_sc_hd__decap_3
XFILLER_84_29 VGND VGND VPWR VPWR sky130_fd_sc_hd__fill_2
XFILLER_29_569 VGND VGND VPWR VPWR sky130_fd_sc_hd__decap_3
XFILLER_84_642 VGND VGND VPWR VPWR sky130_fd_sc_hd__fill_2
X_5099_ _5099_/A _5100_/A VGND VGND VPWR VPWR _5099_/X sky130_fd_sc_hd__or2_2
X_4119_ _7236_/Q _4433_/B _4399_/A2 _7396_/Q _4118_/X VGND VGND VPWR VPWR _4119_/X
+ sky130_fd_sc_hd__a221o_2
XFILLER_16_219 VGND VGND VPWR VPWR sky130_fd_sc_hd__decap_3
XFILLER_71_314 VGND VGND VPWR VPWR sky130_fd_sc_hd__decap_3
XFILLER_83_152 VGND VGND VPWR VPWR sky130_fd_sc_hd__fill_1
XFILLER_83_196 VGND VGND VPWR VPWR sky130_fd_sc_hd__decap_3
XTAP_TAPCELL_ROW_108_1492 VGND VPWR sky130_fd_sc_hd__tapvpwrvgnd_1
XTAP_TAPCELL_ROW_108_1481 VGND VPWR sky130_fd_sc_hd__tapvpwrvgnd_1
XFILLER_24_230 VGND VGND VPWR VPWR sky130_fd_sc_hd__decap_3
XTAP_TAPCELL_ROW_42_718 VGND VPWR sky130_fd_sc_hd__tapvpwrvgnd_1
XFILLER_12_447 VGND VGND VPWR VPWR sky130_fd_sc_hd__decap_3
XFILLER_33_55 VGND VGND VPWR VPWR sky130_fd_sc_hd__fill_1
XFILLER_8_418 VGND VGND VPWR VPWR sky130_fd_sc_hd__fill_2
XTAP_TAPCELL_ROW_22_486 VGND VPWR sky130_fd_sc_hd__tapvpwrvgnd_1
XFILLER_20_491 VGND VGND VPWR VPWR sky130_fd_sc_hd__fill_2
XFILLER_4_613 VGND VGND VPWR VPWR sky130_fd_sc_hd__decap_3
XFILLER_3_167 VGND VGND VPWR VPWR sky130_fd_sc_hd__fill_1
XFILLER_3_178 VGND VGND VPWR VPWR sky130_fd_sc_hd__decap_3
XFILLER_79_458 VGND VGND VPWR VPWR sky130_fd_sc_hd__decap_3
XTAP_TAPCELL_ROW_72_1068 VGND VPWR sky130_fd_sc_hd__tapvpwrvgnd_1
XTAP_TAPCELL_ROW_72_1057 VGND VPWR sky130_fd_sc_hd__tapvpwrvgnd_1
XFILLER_58_74 VGND VGND VPWR VPWR sky130_fd_sc_hd__decap_3
XFILLER_67_609 VGND VGND VPWR VPWR sky130_fd_sc_hd__decap_3
XFILLER_47_311 VGND VGND VPWR VPWR sky130_fd_sc_hd__fill_1
XFILLER_58_96 VGND VGND VPWR VPWR sky130_fd_sc_hd__decap_3
XFILLER_87_480 VGND VGND VPWR VPWR sky130_fd_sc_hd__decap_3
XFILLER_101_290 VGND VGND VPWR VPWR sky130_fd_sc_hd__decap_3
XFILLER_47_333 VGND VGND VPWR VPWR sky130_fd_sc_hd__decap_3
XFILLER_74_130 VGND VGND VPWR VPWR sky130_fd_sc_hd__decap_3
XFILLER_74_141 VGND VGND VPWR VPWR sky130_fd_sc_hd__decap_3
XFILLER_62_314 VGND VGND VPWR VPWR sky130_fd_sc_hd__decap_3
XFILLER_74_174 VGND VGND VPWR VPWR sky130_fd_sc_hd__decap_3
XFILLER_62_347 VGND VGND VPWR VPWR sky130_fd_sc_hd__decap_3
XFILLER_90_645 VGND VGND VPWR VPWR sky130_fd_sc_hd__decap_3
XFILLER_43_561 VGND VGND VPWR VPWR sky130_fd_sc_hd__decap_3
XFILLER_15_263 VGND VGND VPWR VPWR sky130_fd_sc_hd__decap_3
XFILLER_30_200 VGND VGND VPWR VPWR sky130_fd_sc_hd__decap_3
XFILLER_70_380 VGND VGND VPWR VPWR sky130_fd_sc_hd__decap_3
XTAP_TAPCELL_ROW_83_1186 VGND VPWR sky130_fd_sc_hd__tapvpwrvgnd_1
XFILLER_30_233 VGND VGND VPWR VPWR sky130_fd_sc_hd__fill_1
XFILLER_30_277 VGND VGND VPWR VPWR sky130_fd_sc_hd__decap_3
XFILLER_30_299 VGND VGND VPWR VPWR sky130_fd_sc_hd__decap_3
XFILLER_7_473 VGND VGND VPWR VPWR sky130_fd_sc_hd__fill_1
X_4470_ _3346_/A _3927_/X _4466_/Y _4469_/X VGND VGND VPWR VPWR _4470_/X sky130_fd_sc_hd__a31o_2
XFILLER_7_495 VGND VGND VPWR VPWR sky130_fd_sc_hd__decap_3
X_3421_ _4537_/B _3421_/B _3421_/C VGND VGND VPWR VPWR _3423_/C sky130_fd_sc_hd__or3_4
XFILLER_99_92 VGND VGND VPWR VPWR sky130_fd_sc_hd__decap_3
X_3352_ _3420_/A _5642_/B VGND VGND VPWR VPWR _3469_/B sky130_fd_sc_hd__nor2_2
XFILLER_57_108 VGND VGND VPWR VPWR sky130_fd_sc_hd__decap_3
XFILLER_85_406 VGND VGND VPWR VPWR sky130_fd_sc_hd__decap_3
XFILLER_38_322 VGND VGND VPWR VPWR sky130_fd_sc_hd__decap_3
XFILLER_66_631 VGND VGND VPWR VPWR sky130_fd_sc_hd__decap_3
XFILLER_85_439 VGND VGND VPWR VPWR sky130_fd_sc_hd__fill_2
Xhold1107 _7138_/Q VGND VGND VPWR VPWR _5390_/A0 sky130_fd_sc_hd__dlygate4sd3_1
Xhold1118 _7321_/Q VGND VGND VPWR VPWR _4517_/A0 sky130_fd_sc_hd__dlygate4sd3_1
Xhold1129 _7137_/Q VGND VGND VPWR VPWR _5392_/A0 sky130_fd_sc_hd__dlygate4sd3_1
X_5022_ _3548_/X _5017_/Y _5020_/X _5021_/X VGND VGND VPWR VPWR _5661_/A sky130_fd_sc_hd__o211a_2
XFILLER_26_528 VGND VGND VPWR VPWR sky130_fd_sc_hd__decap_3
XFILLER_38_388 VGND VGND VPWR VPWR sky130_fd_sc_hd__decap_3
XFILLER_93_472 VGND VGND VPWR VPWR sky130_fd_sc_hd__fill_1
XFILLER_19_591 VGND VGND VPWR VPWR sky130_fd_sc_hd__decap_3
XFILLER_53_325 VGND VGND VPWR VPWR sky130_fd_sc_hd__decap_3
XFILLER_65_196 VGND VGND VPWR VPWR sky130_fd_sc_hd__decap_3
XFILLER_80_133 VGND VGND VPWR VPWR sky130_fd_sc_hd__fill_1
XFILLER_93_494 VGND VGND VPWR VPWR sky130_fd_sc_hd__fill_1
X_6973_ clkload3/A _6973_/D VGND VGND VPWR VPWR _6973_/Q sky130_fd_sc_hd__dfxtp_2
XFILLER_34_561 VGND VGND VPWR VPWR sky130_fd_sc_hd__decap_3
XFILLER_80_166 VGND VGND VPWR VPWR sky130_fd_sc_hd__decap_3
XFILLER_21_222 VGND VGND VPWR VPWR sky130_fd_sc_hd__fill_2
XFILLER_61_391 VGND VGND VPWR VPWR sky130_fd_sc_hd__fill_1
X_4806_ _3346_/A _3701_/X _4799_/X _4805_/X VGND VGND VPWR VPWR _4806_/X sky130_fd_sc_hd__a31o_2
XFILLER_21_277 VGND VGND VPWR VPWR sky130_fd_sc_hd__decap_3
X_4737_ _7005_/Q _4775_/A _7006_/Q VGND VGND VPWR VPWR _4738_/B sky130_fd_sc_hd__a21oi_2
X_4668_ _4908_/A _4896_/A VGND VGND VPWR VPWR _4668_/X sky130_fd_sc_hd__and2_2
Xhold930 _7020_/Q VGND VGND VPWR VPWR _5615_/A sky130_fd_sc_hd__dlygate4sd3_1
X_6407_ _6636_/A VGND VGND VPWR VPWR _6407_/Y sky130_fd_sc_hd__inv_2
X_3619_ _3620_/A _3620_/C _4292_/B VGND VGND VPWR VPWR _3619_/Y sky130_fd_sc_hd__o21ai_2
XFILLER_1_605 VGND VGND VPWR VPWR sky130_fd_sc_hd__decap_3
X_7387_ _7387_/CLK _7387_/D _6667_/Y VGND VGND VPWR VPWR _7387_/Q sky130_fd_sc_hd__dfrtp_2
Xhold963 _7389_/Q VGND VGND VPWR VPWR hold963/X sky130_fd_sc_hd__dlygate4sd3_1
Xhold952 _7053_/Q VGND VGND VPWR VPWR hold952/X sky130_fd_sc_hd__dlygate4sd3_1
Xhold941 _6716_/Q VGND VGND VPWR VPWR hold941/X sky130_fd_sc_hd__dlygate4sd3_1
X_4599_ _4599_/A0 _5142_/A0 _4599_/S VGND VGND VPWR VPWR _7281_/D sky130_fd_sc_hd__mux2_2
XFILLER_103_511 VGND VGND VPWR VPWR sky130_fd_sc_hd__decap_3
XFILLER_88_211 VGND VGND VPWR VPWR sky130_fd_sc_hd__decap_3
Xhold996 _7192_/Q VGND VGND VPWR VPWR hold996/X sky130_fd_sc_hd__dlygate4sd3_1
Xhold985 _7379_/Q VGND VGND VPWR VPWR hold985/X sky130_fd_sc_hd__dlygate4sd3_1
Xhold974 _7399_/Q VGND VGND VPWR VPWR hold974/X sky130_fd_sc_hd__dlygate4sd3_1
X_6338_ _6536_/A VGND VGND VPWR VPWR _6338_/Y sky130_fd_sc_hd__inv_2
XFILLER_49_609 VGND VGND VPWR VPWR sky130_fd_sc_hd__decap_3
X_6269_ _6684_/A VGND VGND VPWR VPWR _6269_/Y sky130_fd_sc_hd__inv_2
XFILLER_103_588 VGND VGND VPWR VPWR sky130_fd_sc_hd__decap_3
XFILLER_28_11 VGND VGND VPWR VPWR sky130_fd_sc_hd__decap_3
XFILLER_28_22 VGND VGND VPWR VPWR sky130_fd_sc_hd__fill_1
XFILLER_29_300 VGND VGND VPWR VPWR sky130_fd_sc_hd__decap_3
XFILLER_57_620 VGND VGND VPWR VPWR sky130_fd_sc_hd__decap_3
XFILLER_29_388 VGND VGND VPWR VPWR sky130_fd_sc_hd__fill_1
XFILLER_56_141 VGND VGND VPWR VPWR sky130_fd_sc_hd__decap_3
XFILLER_56_174 VGND VGND VPWR VPWR sky130_fd_sc_hd__decap_3
XFILLER_84_461 VGND VGND VPWR VPWR sky130_fd_sc_hd__decap_3
XFILLER_71_111 VGND VGND VPWR VPWR sky130_fd_sc_hd__fill_1
XFILLER_72_645 VGND VGND VPWR VPWR sky130_fd_sc_hd__decap_3
XFILLER_71_155 VGND VGND VPWR VPWR sky130_fd_sc_hd__decap_3
XTAP_TAPCELL_ROW_55_865 VGND VPWR sky130_fd_sc_hd__tapvpwrvgnd_1
XTAP_TAPCELL_ROW_27_545 VGND VPWR sky130_fd_sc_hd__tapvpwrvgnd_1
XFILLER_12_200 VGND VGND VPWR VPWR sky130_fd_sc_hd__decap_3
XFILLER_71_188 VGND VGND VPWR VPWR sky130_fd_sc_hd__decap_3
XFILLER_12_233 VGND VGND VPWR VPWR sky130_fd_sc_hd__decap_3
XFILLER_40_542 VGND VGND VPWR VPWR sky130_fd_sc_hd__decap_3
XFILLER_40_553 VGND VGND VPWR VPWR sky130_fd_sc_hd__fill_2
XFILLER_8_248 VGND VGND VPWR VPWR sky130_fd_sc_hd__decap_3
XFILLER_8_259 VGND VGND VPWR VPWR sky130_fd_sc_hd__decap_3
XFILLER_5_15 VGND VGND VPWR VPWR sky130_fd_sc_hd__decap_3
XFILLER_106_371 VGND VGND VPWR VPWR sky130_fd_sc_hd__decap_3
XFILLER_106_393 VGND VGND VPWR VPWR sky130_fd_sc_hd__decap_3
XFILLER_79_211 VGND VGND VPWR VPWR sky130_fd_sc_hd__decap_3
XFILLER_79_244 VGND VGND VPWR VPWR sky130_fd_sc_hd__decap_3
XFILLER_39_119 VGND VGND VPWR VPWR sky130_fd_sc_hd__decap_3
XFILLER_67_417 VGND VGND VPWR VPWR sky130_fd_sc_hd__decap_3
XFILLER_67_428 VGND VGND VPWR VPWR sky130_fd_sc_hd__decap_3
XFILLER_48_631 VGND VGND VPWR VPWR sky130_fd_sc_hd__decap_3
XFILLER_94_247 VGND VGND VPWR VPWR sky130_fd_sc_hd__decap_3
XPHY_EDGE_ROW_13_Right_13 VGND VGND VPWR VPWR sky130_fd_sc_hd__decap_3
XFILLER_47_152 VGND VGND VPWR VPWR sky130_fd_sc_hd__decap_3
XFILLER_63_623 VGND VGND VPWR VPWR sky130_fd_sc_hd__decap_3
XTAP_TAPCELL_ROW_85_1215 VGND VPWR sky130_fd_sc_hd__tapvpwrvgnd_1
XFILLER_62_144 VGND VGND VPWR VPWR sky130_fd_sc_hd__fill_2
X_3970_ _7355_/Q _4513_/A0 _3989_/S VGND VGND VPWR VPWR _7355_/D sky130_fd_sc_hd__mux2_2
XFILLER_16_583 VGND VGND VPWR VPWR sky130_fd_sc_hd__decap_3
XFILLER_31_586 VGND VGND VPWR VPWR sky130_fd_sc_hd__decap_3
X_5640_ _5642_/A _5640_/B VGND VGND VPWR VPWR _5640_/Y sky130_fd_sc_hd__nor2_2
X_5571_ hold940/X _5647_/A _4944_/C VGND VGND VPWR VPWR _7046_/D sky130_fd_sc_hd__a21o_2
XPHY_EDGE_ROW_22_Right_22 VGND VGND VPWR VPWR sky130_fd_sc_hd__decap_3
X_7310_ _7374_/CLK _7310_/D _6590_/Y VGND VGND VPWR VPWR _7310_/Q sky130_fd_sc_hd__dfrtp_2
X_4522_ _4522_/A0 _4589_/A _4532_/S VGND VGND VPWR VPWR _7318_/D sky130_fd_sc_hd__mux2_2
XTAP_TAPCELL_ROW_96_1344 VGND VPWR sky130_fd_sc_hd__tapvpwrvgnd_1
XTAP_TAPCELL_ROW_96_1333 VGND VPWR sky130_fd_sc_hd__tapvpwrvgnd_1
XFILLER_7_270 VGND VGND VPWR VPWR sky130_fd_sc_hd__decap_3
XFILLER_7_281 VGND VGND VPWR VPWR sky130_fd_sc_hd__decap_3
X_7241_ _7276_/CLK _7241_/D _6521_/Y VGND VGND VPWR VPWR _7241_/Q sky130_fd_sc_hd__dfrtp_2
X_4453_ _4453_/A VGND VGND VPWR VPWR _4762_/B sky130_fd_sc_hd__inv_2
X_7172_ _7361_/CLK _7172_/D _6452_/Y VGND VGND VPWR VPWR _7172_/Q sky130_fd_sc_hd__dfrtp_2
X_4384_ _4384_/A _4968_/A _4384_/C VGND VGND VPWR VPWR _4778_/B sky130_fd_sc_hd__nand3_2
XFILLER_98_542 VGND VGND VPWR VPWR sky130_fd_sc_hd__decap_3
X_3335_ _3319_/X _5238_/B _3329_/Y _3339_/C1 VGND VGND VPWR VPWR _3874_/A sky130_fd_sc_hd__a211o_2
XFILLER_100_536 VGND VGND VPWR VPWR sky130_fd_sc_hd__decap_3
XFILLER_105_38 VGND VGND VPWR VPWR sky130_fd_sc_hd__decap_3
XFILLER_39_620 VGND VGND VPWR VPWR sky130_fd_sc_hd__decap_3
XFILLER_58_417 VGND VGND VPWR VPWR sky130_fd_sc_hd__decap_3
XFILLER_58_428 VGND VGND VPWR VPWR sky130_fd_sc_hd__fill_1
XFILLER_85_225 VGND VGND VPWR VPWR sky130_fd_sc_hd__decap_3
XPHY_EDGE_ROW_31_Right_31 VGND VGND VPWR VPWR sky130_fd_sc_hd__decap_3
XFILLER_38_130 VGND VGND VPWR VPWR sky130_fd_sc_hd__decap_3
X_5005_ _5004_/A _5004_/B _4814_/A VGND VGND VPWR VPWR _5005_/Y sky130_fd_sc_hd__a21oi_2
XFILLER_38_141 VGND VGND VPWR VPWR sky130_fd_sc_hd__decap_3
XFILLER_66_450 VGND VGND VPWR VPWR sky130_fd_sc_hd__decap_3
XFILLER_53_111 VGND VGND VPWR VPWR sky130_fd_sc_hd__fill_1
XFILLER_53_122 VGND VGND VPWR VPWR sky130_fd_sc_hd__decap_3
XFILLER_54_623 VGND VGND VPWR VPWR sky130_fd_sc_hd__decap_3
XFILLER_54_645 VGND VGND VPWR VPWR sky130_fd_sc_hd__decap_3
XFILLER_53_144 VGND VGND VPWR VPWR sky130_fd_sc_hd__decap_3
X_6956_ _6974_/CLK _6956_/D VGND VGND VPWR VPWR _6956_/Q sky130_fd_sc_hd__dfxtp_2
XTAP_TAPCELL_ROW_105_1440 VGND VPWR sky130_fd_sc_hd__tapvpwrvgnd_1
XFILLER_41_317 VGND VGND VPWR VPWR sky130_fd_sc_hd__decap_3
XTAP_TAPCELL_ROW_52_835 VGND VPWR sky130_fd_sc_hd__tapvpwrvgnd_1
XTAP_TAPCELL_ROW_24_515 VGND VPWR sky130_fd_sc_hd__tapvpwrvgnd_1
XFILLER_14_24 VGND VGND VPWR VPWR sky130_fd_sc_hd__decap_3
X_6887_ _6968_/CLK _6887_/D VGND VGND VPWR VPWR _6887_/Q sky130_fd_sc_hd__dfxtp_2
XFILLER_14_68 VGND VGND VPWR VPWR sky130_fd_sc_hd__decap_3
XFILLER_22_586 VGND VGND VPWR VPWR sky130_fd_sc_hd__fill_2
XPHY_EDGE_ROW_40_Right_40 VGND VGND VPWR VPWR sky130_fd_sc_hd__decap_3
XFILLER_108_614 VGND VGND VPWR VPWR sky130_fd_sc_hd__fill_2
XPHY_EDGE_ROW_15_Left_124 VGND VGND VPWR VPWR sky130_fd_sc_hd__decap_3
XFILLER_107_113 VGND VGND VPWR VPWR sky130_fd_sc_hd__fill_1
Xhold760 _6775_/Q VGND VGND VPWR VPWR _6775_/D sky130_fd_sc_hd__dlygate4sd3_1
Xhold771 _6772_/Q VGND VGND VPWR VPWR _6772_/D sky130_fd_sc_hd__dlygate4sd3_1
Xhold782 _6762_/Q VGND VGND VPWR VPWR _6762_/D sky130_fd_sc_hd__dlygate4sd3_1
XFILLER_103_352 VGND VGND VPWR VPWR sky130_fd_sc_hd__decap_3
XFILLER_1_446 VGND VGND VPWR VPWR sky130_fd_sc_hd__fill_2
XFILLER_49_406 VGND VGND VPWR VPWR sky130_fd_sc_hd__fill_1
Xhold793 _6880_/Q VGND VGND VPWR VPWR _6880_/D sky130_fd_sc_hd__dlygate4sd3_1
XFILLER_49_428 VGND VGND VPWR VPWR sky130_fd_sc_hd__decap_3
XFILLER_76_203 VGND VGND VPWR VPWR sky130_fd_sc_hd__decap_3
XFILLER_89_586 VGND VGND VPWR VPWR sky130_fd_sc_hd__decap_3
XFILLER_103_396 VGND VGND VPWR VPWR sky130_fd_sc_hd__decap_3
XFILLER_29_163 VGND VGND VPWR VPWR sky130_fd_sc_hd__decap_3
XFILLER_91_206 VGND VGND VPWR VPWR sky130_fd_sc_hd__decap_3
XTAP_TAPCELL_ROW_4_284 VGND VPWR sky130_fd_sc_hd__tapvpwrvgnd_1
XPHY_EDGE_ROW_24_Left_133 VGND VGND VPWR VPWR sky130_fd_sc_hd__decap_3
XFILLER_29_196 VGND VGND VPWR VPWR sky130_fd_sc_hd__decap_3
XFILLER_44_111 VGND VGND VPWR VPWR sky130_fd_sc_hd__fill_1
XFILLER_45_623 VGND VGND VPWR VPWR sky130_fd_sc_hd__decap_3
XFILLER_55_53 VGND VGND VPWR VPWR sky130_fd_sc_hd__decap_3
XFILLER_57_494 VGND VGND VPWR VPWR sky130_fd_sc_hd__decap_3
XFILLER_91_228 VGND VGND VPWR VPWR sky130_fd_sc_hd__decap_3
XFILLER_17_358 VGND VGND VPWR VPWR sky130_fd_sc_hd__decap_3
XFILLER_44_144 VGND VGND VPWR VPWR sky130_fd_sc_hd__decap_3
XFILLER_55_86 VGND VGND VPWR VPWR sky130_fd_sc_hd__decap_3
XFILLER_72_464 VGND VGND VPWR VPWR sky130_fd_sc_hd__decap_3
XFILLER_32_317 VGND VGND VPWR VPWR sky130_fd_sc_hd__decap_3
XFILLER_44_177 VGND VGND VPWR VPWR sky130_fd_sc_hd__decap_3
XFILLER_60_615 VGND VGND VPWR VPWR sky130_fd_sc_hd__decap_3
XFILLER_72_497 VGND VGND VPWR VPWR sky130_fd_sc_hd__decap_3
XFILLER_25_391 VGND VGND VPWR VPWR sky130_fd_sc_hd__fill_1
XFILLER_13_564 VGND VGND VPWR VPWR sky130_fd_sc_hd__decap_3
XFILLER_71_63 VGND VGND VPWR VPWR sky130_fd_sc_hd__fill_1
XTAP_TAPCELL_ROW_80_1156 VGND VPWR sky130_fd_sc_hd__tapvpwrvgnd_1
XFILLER_13_597 VGND VGND VPWR VPWR sky130_fd_sc_hd__decap_3
XPHY_EDGE_ROW_33_Left_142 VGND VGND VPWR VPWR sky130_fd_sc_hd__decap_3
XFILLER_9_546 VGND VGND VPWR VPWR sky130_fd_sc_hd__decap_3
XFILLER_9_579 VGND VGND VPWR VPWR sky130_fd_sc_hd__decap_3
XFILLER_67_214 VGND VGND VPWR VPWR sky130_fd_sc_hd__decap_3
XTAP_TAPCELL_ROW_91_1285 VGND VPWR sky130_fd_sc_hd__tapvpwrvgnd_1
XFILLER_96_60 VGND VGND VPWR VPWR sky130_fd_sc_hd__decap_3
XFILLER_67_236 VGND VGND VPWR VPWR sky130_fd_sc_hd__decap_3
XPHY_EDGE_ROW_42_Left_151 VGND VGND VPWR VPWR sky130_fd_sc_hd__decap_3
XFILLER_95_545 VGND VGND VPWR VPWR sky130_fd_sc_hd__decap_3
XFILLER_67_269 VGND VGND VPWR VPWR sky130_fd_sc_hd__decap_3
XFILLER_36_623 VGND VGND VPWR VPWR sky130_fd_sc_hd__decap_3
XFILLER_36_645 VGND VGND VPWR VPWR sky130_fd_sc_hd__decap_3
XFILLER_48_483 VGND VGND VPWR VPWR sky130_fd_sc_hd__decap_3
XFILLER_82_239 VGND VGND VPWR VPWR sky130_fd_sc_hd__decap_3
XFILLER_35_133 VGND VGND VPWR VPWR sky130_fd_sc_hd__decap_3
Xplace420 _3966_/S VGND VGND VPWR VPWR _4414_/B1 sky130_fd_sc_hd__buf_2
Xplace431 _3366_/X VGND VGND VPWR VPWR _4348_/A2 sky130_fd_sc_hd__buf_2
X_6810_ _6958_/CLK _6810_/D VGND VGND VPWR VPWR _6810_/Q sky130_fd_sc_hd__dfxtp_2
XFILLER_51_626 VGND VGND VPWR VPWR sky130_fd_sc_hd__decap_3
XFILLER_63_475 VGND VGND VPWR VPWR sky130_fd_sc_hd__decap_3
Xplace442 _4353_/A2 VGND VGND VPWR VPWR _4414_/A2 sky130_fd_sc_hd__buf_2
Xplace453 _3365_/A VGND VGND VPWR VPWR _3327_/B sky130_fd_sc_hd__buf_2
XFILLER_16_391 VGND VGND VPWR VPWR sky130_fd_sc_hd__decap_3
XFILLER_35_199 VGND VGND VPWR VPWR sky130_fd_sc_hd__decap_3
XFILLER_50_136 VGND VGND VPWR VPWR sky130_fd_sc_hd__decap_3
XFILLER_50_147 VGND VGND VPWR VPWR sky130_fd_sc_hd__decap_3
X_6741_ clkload7/A _6741_/D VGND VGND VPWR VPWR _6741_/Q sky130_fd_sc_hd__dfxtp_2
X_6672_ _6678_/A VGND VGND VPWR VPWR _6672_/Y sky130_fd_sc_hd__inv_2
X_3884_ _6824_/Q _3884_/A2 _3884_/B1 _6809_/Q _3883_/X VGND VGND VPWR VPWR _3884_/X
+ sky130_fd_sc_hd__a221o_2
XPHY_EDGE_ROW_51_Left_160 VGND VGND VPWR VPWR sky130_fd_sc_hd__decap_3
XTAP_TAPCELL_ROW_100_1381 VGND VPWR sky130_fd_sc_hd__tapvpwrvgnd_1
XFILLER_105_606 VGND VGND VPWR VPWR sky130_fd_sc_hd__fill_2
XFILLER_105_617 VGND VGND VPWR VPWR sky130_fd_sc_hd__decap_3
X_4505_ _4505_/A0 _7295_/Q _4520_/S VGND VGND VPWR VPWR _7327_/D sky130_fd_sc_hd__mux2_2
XFILLER_6_91 VGND VGND VPWR VPWR sky130_fd_sc_hd__decap_3
X_7224_ _7355_/CLK _7224_/D _6504_/Y VGND VGND VPWR VPWR _7224_/Q sky130_fd_sc_hd__dfrtp_2
X_4436_ _7303_/Q _4998_/S _4436_/B1 _7175_/Q _4435_/X VGND VGND VPWR VPWR _4436_/X
+ sky130_fd_sc_hd__a221o_2
X_7155_ _7349_/CLK _7155_/D _6435_/Y VGND VGND VPWR VPWR _7155_/Q sky130_fd_sc_hd__dfrtp_2
X_4367_ _4367_/A _4367_/B _4367_/C VGND VGND VPWR VPWR _5054_/A sky130_fd_sc_hd__and3_2
XFILLER_58_203 VGND VGND VPWR VPWR sky130_fd_sc_hd__decap_3
X_3318_ _3353_/B _3332_/B VGND VGND VPWR VPWR _5647_/B sky130_fd_sc_hd__nand2_2
XFILLER_58_247 VGND VGND VPWR VPWR sky130_fd_sc_hd__decap_3
XFILLER_86_545 VGND VGND VPWR VPWR sky130_fd_sc_hd__fill_1
X_7086_ _7406_/CLK _7086_/D _6366_/Y VGND VGND VPWR VPWR _7086_/Q sky130_fd_sc_hd__dfrtp_2
X_4298_ _3620_/C _4292_/X _4293_/X _4297_/Y VGND VGND VPWR VPWR _4298_/X sky130_fd_sc_hd__a211o_2
XFILLER_100_355 VGND VGND VPWR VPWR sky130_fd_sc_hd__decap_3
XFILLER_100_377 VGND VGND VPWR VPWR sky130_fd_sc_hd__fill_2
XFILLER_27_612 VGND VGND VPWR VPWR sky130_fd_sc_hd__decap_3
XFILLER_86_589 VGND VGND VPWR VPWR sky130_fd_sc_hd__fill_1
XFILLER_100_388 VGND VGND VPWR VPWR sky130_fd_sc_hd__decap_3
XFILLER_26_111 VGND VGND VPWR VPWR sky130_fd_sc_hd__decap_3
XFILLER_27_623 VGND VGND VPWR VPWR sky130_fd_sc_hd__decap_3
XFILLER_39_472 VGND VGND VPWR VPWR sky130_fd_sc_hd__decap_3
XTAP_TAPCELL_ROW_1_243 VGND VPWR sky130_fd_sc_hd__tapvpwrvgnd_1
XFILLER_26_144 VGND VGND VPWR VPWR sky130_fd_sc_hd__decap_3
XFILLER_26_155 VGND VGND VPWR VPWR sky130_fd_sc_hd__decap_3
XFILLER_54_464 VGND VGND VPWR VPWR sky130_fd_sc_hd__decap_3
XFILLER_92_29 VGND VGND VPWR VPWR sky130_fd_sc_hd__decap_3
XFILLER_26_177 VGND VGND VPWR VPWR sky130_fd_sc_hd__decap_3
XFILLER_42_615 VGND VGND VPWR VPWR sky130_fd_sc_hd__decap_3
XTAP_TAPCELL_ROW_65_982 VGND VPWR sky130_fd_sc_hd__tapvpwrvgnd_1
XTAP_TAPCELL_ROW_37_662 VGND VPWR sky130_fd_sc_hd__tapvpwrvgnd_1
XFILLER_14_339 VGND VGND VPWR VPWR sky130_fd_sc_hd__decap_3
XFILLER_25_78 VGND VGND VPWR VPWR sky130_fd_sc_hd__decap_3
X_6939_ _6943_/CLK _6939_/D VGND VGND VPWR VPWR _6939_/Q sky130_fd_sc_hd__dfxtp_2
XFILLER_41_158 VGND VGND VPWR VPWR sky130_fd_sc_hd__decap_3
XFILLER_41_169 VGND VGND VPWR VPWR sky130_fd_sc_hd__decap_3
XFILLER_22_383 VGND VGND VPWR VPWR sky130_fd_sc_hd__decap_3
XFILLER_10_589 VGND VGND VPWR VPWR sky130_fd_sc_hd__decap_3
XFILLER_108_455 VGND VGND VPWR VPWR sky130_fd_sc_hd__fill_1
XFILLER_108_488 VGND VGND VPWR VPWR sky130_fd_sc_hd__decap_3
XTAP_TAPCELL_ROW_9_343 VGND VPWR sky130_fd_sc_hd__tapvpwrvgnd_1
XFILLER_1_243 VGND VGND VPWR VPWR sky130_fd_sc_hd__decap_3
Xhold590 _6727_/Q VGND VGND VPWR VPWR _6727_/D sky130_fd_sc_hd__dlygate4sd3_1
XFILLER_89_361 VGND VGND VPWR VPWR sky130_fd_sc_hd__decap_3
XFILLER_2_27 VGND VGND VPWR VPWR sky130_fd_sc_hd__fill_1
XFILLER_18_601 VGND VGND VPWR VPWR sky130_fd_sc_hd__decap_3
XFILLER_66_41 VGND VGND VPWR VPWR sky130_fd_sc_hd__decap_3
XFILLER_92_515 VGND VGND VPWR VPWR sky130_fd_sc_hd__decap_3
XFILLER_17_100 VGND VGND VPWR VPWR sky130_fd_sc_hd__decap_3
XFILLER_18_634 VGND VGND VPWR VPWR sky130_fd_sc_hd__decap_3
XFILLER_18_645 VGND VGND VPWR VPWR sky130_fd_sc_hd__decap_3
XFILLER_64_217 VGND VGND VPWR VPWR sky130_fd_sc_hd__decap_3
XFILLER_66_85 VGND VGND VPWR VPWR sky130_fd_sc_hd__decap_3
XFILLER_92_559 VGND VGND VPWR VPWR sky130_fd_sc_hd__decap_3
XTAP_TAPCELL_ROW_69_1029 VGND VPWR sky130_fd_sc_hd__tapvpwrvgnd_1
XFILLER_17_122 VGND VGND VPWR VPWR sky130_fd_sc_hd__decap_3
XFILLER_33_604 VGND VGND VPWR VPWR sky130_fd_sc_hd__decap_3
XFILLER_45_442 VGND VGND VPWR VPWR sky130_fd_sc_hd__decap_3
XFILLER_45_453 VGND VGND VPWR VPWR sky130_fd_sc_hd__decap_3
XFILLER_33_626 VGND VGND VPWR VPWR sky130_fd_sc_hd__decap_3
XFILLER_60_401 VGND VGND VPWR VPWR sky130_fd_sc_hd__decap_3
XFILLER_72_250 VGND VGND VPWR VPWR sky130_fd_sc_hd__fill_2
XFILLER_72_272 VGND VGND VPWR VPWR sky130_fd_sc_hd__decap_3
XFILLER_60_434 VGND VGND VPWR VPWR sky130_fd_sc_hd__decap_3
XFILLER_13_361 VGND VGND VPWR VPWR sky130_fd_sc_hd__fill_1
XFILLER_32_158 VGND VGND VPWR VPWR sky130_fd_sc_hd__decap_3
XFILLER_13_372 VGND VGND VPWR VPWR sky130_fd_sc_hd__decap_3
XTAP_TAPCELL_ROW_93_1303 VGND VPWR sky130_fd_sc_hd__tapvpwrvgnd_1
XFILLER_5_582 VGND VGND VPWR VPWR sky130_fd_sc_hd__decap_3
X_5270_ _5270_/A0 _5040_/X _5292_/S VGND VGND VPWR VPWR _7195_/D sky130_fd_sc_hd__mux2_2
XFILLER_99_125 VGND VGND VPWR VPWR sky130_fd_sc_hd__decap_3
X_4221_ _7228_/Q _4353_/A2 _4244_/B _7041_/Q _4220_/X VGND VGND VPWR VPWR _4221_/X
+ sky130_fd_sc_hd__a221o_2
XFILLER_99_169 VGND VGND VPWR VPWR sky130_fd_sc_hd__decap_3
XFILLER_99_158 VGND VGND VPWR VPWR sky130_fd_sc_hd__decap_3
X_4152_ _7106_/Q _4351_/A2 _4267_/A2 _7138_/Q VGND VGND VPWR VPWR _4152_/X sky130_fd_sc_hd__a22o_2
XFILLER_68_578 VGND VGND VPWR VPWR sky130_fd_sc_hd__fill_2
X_4083_ _7366_/Q _4261_/A2 _4261_/B1 _7174_/Q VGND VGND VPWR VPWR _4083_/X sky130_fd_sc_hd__a22o_2
XFILLER_55_217 VGND VGND VPWR VPWR sky130_fd_sc_hd__decap_3
XFILLER_55_228 VGND VGND VPWR VPWR sky130_fd_sc_hd__decap_3
XFILLER_83_537 VGND VGND VPWR VPWR sky130_fd_sc_hd__decap_3
XFILLER_48_291 VGND VGND VPWR VPWR sky130_fd_sc_hd__decap_3
XFILLER_24_604 VGND VGND VPWR VPWR sky130_fd_sc_hd__decap_3
XFILLER_24_637 VGND VGND VPWR VPWR sky130_fd_sc_hd__decap_3
XFILLER_36_475 VGND VGND VPWR VPWR sky130_fd_sc_hd__fill_1
XFILLER_36_486 VGND VGND VPWR VPWR sky130_fd_sc_hd__decap_3
XFILLER_36_497 VGND VGND VPWR VPWR sky130_fd_sc_hd__decap_3
XFILLER_51_401 VGND VGND VPWR VPWR sky130_fd_sc_hd__decap_3
XFILLER_91_570 VGND VGND VPWR VPWR sky130_fd_sc_hd__decap_3
XFILLER_23_147 VGND VGND VPWR VPWR sky130_fd_sc_hd__decap_3
XFILLER_51_434 VGND VGND VPWR VPWR sky130_fd_sc_hd__decap_3
Xplace272 _3925_/B1 VGND VGND VPWR VPWR _3887_/B1 sky130_fd_sc_hd__buf_2
X_4985_ _4620_/A _5032_/A _5031_/B _4630_/X VGND VGND VPWR VPWR _5003_/B sky130_fd_sc_hd__a31o_2
XTAP_TAPCELL_ROW_62_952 VGND VPWR sky130_fd_sc_hd__tapvpwrvgnd_1
XTAP_TAPCELL_ROW_34_621 VGND VPWR sky130_fd_sc_hd__tapvpwrvgnd_1
XTAP_TAPCELL_ROW_102_1410 VGND VPWR sky130_fd_sc_hd__tapvpwrvgnd_1
XFILLER_23_169 VGND VGND VPWR VPWR sky130_fd_sc_hd__decap_3
Xplace294 _3651_/Y VGND VGND VPWR VPWR _3879_/B1 sky130_fd_sc_hd__buf_2
Xplace283 _3884_/B1 VGND VGND VPWR VPWR _3823_/A2 sky130_fd_sc_hd__buf_2
X_6724_ _6974_/CLK _6724_/D VGND VGND VPWR VPWR _6724_/Q sky130_fd_sc_hd__dfxtp_2
X_6655_ _6667_/A VGND VGND VPWR VPWR _6655_/Y sky130_fd_sc_hd__inv_2
X_3867_ _3629_/Y _3866_/X _3867_/B1 VGND VGND VPWR VPWR _3867_/X sky130_fd_sc_hd__o21a_2
X_6586_ _6622_/A VGND VGND VPWR VPWR _6586_/Y sky130_fd_sc_hd__inv_2
X_3798_ _6738_/Q _3879_/B1 _3665_/X _6744_/Q _3797_/X VGND VGND VPWR VPWR _3798_/X
+ sky130_fd_sc_hd__a221o_2
XFILLER_105_414 VGND VGND VPWR VPWR sky130_fd_sc_hd__decap_3
XFILLER_11_69 VGND VGND VPWR VPWR sky130_fd_sc_hd__decap_3
XFILLER_105_458 VGND VGND VPWR VPWR sky130_fd_sc_hd__decap_3
XFILLER_2_9 VGND VGND VPWR VPWR sky130_fd_sc_hd__decap_3
X_7207_ _7405_/CLK _7207_/D _6487_/Y VGND VGND VPWR VPWR _7207_/Q sky130_fd_sc_hd__dfrtp_2
X_4419_ _7304_/Q _4478_/S _4419_/B1 _7368_/Q _4429_/C1 VGND VGND VPWR VPWR _4419_/X
+ sky130_fd_sc_hd__a221o_2
XTAP_TAPCELL_ROW_6_302 VGND VPWR sky130_fd_sc_hd__tapvpwrvgnd_1
X_7138_ _7362_/CLK _7138_/D _6418_/Y VGND VGND VPWR VPWR _7138_/Q sky130_fd_sc_hd__dfrtp_2
XFILLER_98_191 VGND VGND VPWR VPWR sky130_fd_sc_hd__decap_3
XFILLER_100_141 VGND VGND VPWR VPWR sky130_fd_sc_hd__decap_3
XFILLER_86_353 VGND VGND VPWR VPWR sky130_fd_sc_hd__decap_3
XFILLER_86_375 VGND VGND VPWR VPWR sky130_fd_sc_hd__decap_3
X_7069_ _7398_/CLK _7069_/D _6349_/Y VGND VGND VPWR VPWR _7069_/Q sky130_fd_sc_hd__dfrtp_2
XFILLER_46_228 VGND VGND VPWR VPWR sky130_fd_sc_hd__fill_1
XFILLER_86_397 VGND VGND VPWR VPWR sky130_fd_sc_hd__decap_3
XFILLER_15_615 VGND VGND VPWR VPWR sky130_fd_sc_hd__fill_1
XFILLER_15_626 VGND VGND VPWR VPWR sky130_fd_sc_hd__decap_3
XFILLER_54_261 VGND VGND VPWR VPWR sky130_fd_sc_hd__fill_1
XFILLER_14_136 VGND VGND VPWR VPWR sky130_fd_sc_hd__decap_3
XFILLER_42_445 VGND VGND VPWR VPWR sky130_fd_sc_hd__fill_2
XFILLER_54_294 VGND VGND VPWR VPWR sky130_fd_sc_hd__decap_3
XFILLER_14_147 VGND VGND VPWR VPWR sky130_fd_sc_hd__fill_1
XFILLER_30_607 VGND VGND VPWR VPWR sky130_fd_sc_hd__decap_3
XFILLER_42_456 VGND VGND VPWR VPWR sky130_fd_sc_hd__fill_1
XFILLER_10_331 VGND VGND VPWR VPWR sky130_fd_sc_hd__decap_3
XFILLER_22_180 VGND VGND VPWR VPWR sky130_fd_sc_hd__decap_3
XFILLER_6_368 VGND VGND VPWR VPWR sky130_fd_sc_hd__decap_3
XFILLER_108_296 VGND VGND VPWR VPWR sky130_fd_sc_hd__decap_3
XFILLER_2_563 VGND VGND VPWR VPWR sky130_fd_sc_hd__decap_3
XTAP_TAPCELL_ROW_75_1099 VGND VPWR sky130_fd_sc_hd__tapvpwrvgnd_1
XFILLER_104_491 VGND VGND VPWR VPWR sky130_fd_sc_hd__decap_3
XFILLER_77_331 VGND VGND VPWR VPWR sky130_fd_sc_hd__decap_3
XFILLER_37_228 VGND VGND VPWR VPWR sky130_fd_sc_hd__decap_3
XFILLER_77_375 VGND VGND VPWR VPWR sky130_fd_sc_hd__decap_3
XFILLER_77_386 VGND VGND VPWR VPWR sky130_fd_sc_hd__decap_3
XFILLER_92_312 VGND VGND VPWR VPWR sky130_fd_sc_hd__decap_3
XFILLER_18_464 VGND VGND VPWR VPWR sky130_fd_sc_hd__decap_3
XFILLER_80_529 VGND VGND VPWR VPWR sky130_fd_sc_hd__decap_3
XFILLER_18_497 VGND VGND VPWR VPWR sky130_fd_sc_hd__decap_3
XFILLER_73_592 VGND VGND VPWR VPWR sky130_fd_sc_hd__decap_3
XFILLER_21_629 VGND VGND VPWR VPWR sky130_fd_sc_hd__decap_3
XFILLER_60_286 VGND VGND VPWR VPWR sky130_fd_sc_hd__fill_2
X_4770_ _4832_/A _3692_/X _5663_/A _4791_/C1 VGND VGND VPWR VPWR _4770_/X sky130_fd_sc_hd__a211o_2
XFILLER_13_191 VGND VGND VPWR VPWR sky130_fd_sc_hd__decap_3
X_3721_ _6863_/Q _3879_/B1 _3913_/B1 _6855_/Q _3720_/X VGND VGND VPWR VPWR _3721_/X
+ sky130_fd_sc_hd__a221o_2
X_6440_ _6624_/A VGND VGND VPWR VPWR _6440_/Y sky130_fd_sc_hd__inv_2
XFILLER_9_184 VGND VGND VPWR VPWR sky130_fd_sc_hd__decap_3
X_6371_ _6566_/A VGND VGND VPWR VPWR _6371_/Y sky130_fd_sc_hd__inv_2
X_3583_ _3583_/A _3583_/B _3583_/C VGND VGND VPWR VPWR _3583_/X sky130_fd_sc_hd__or3_4
X_5253_ _5253_/A0 _4913_/X _5274_/S VGND VGND VPWR VPWR _7203_/D sky130_fd_sc_hd__mux2_2
XFILLER_68_331 VGND VGND VPWR VPWR sky130_fd_sc_hd__decap_3
X_5184_ _5184_/A _5207_/B VGND VGND VPWR VPWR _7236_/D sky130_fd_sc_hd__and2_2
X_4204_ _4936_/A _4201_/X _4203_/X VGND VGND VPWR VPWR _4204_/Y sky130_fd_sc_hd__o21bai_2
X_4135_ _7107_/Q _4351_/A2 _4434_/B1 _7139_/Q VGND VGND VPWR VPWR _4135_/X sky130_fd_sc_hd__a22o_2
XFILLER_28_239 VGND VGND VPWR VPWR sky130_fd_sc_hd__decap_3
XFILLER_68_397 VGND VGND VPWR VPWR sky130_fd_sc_hd__decap_3
XFILLER_95_172 VGND VGND VPWR VPWR sky130_fd_sc_hd__fill_1
XFILLER_83_367 VGND VGND VPWR VPWR sky130_fd_sc_hd__decap_3
X_4066_ _4062_/X _4065_/X _4425_/A VGND VGND VPWR VPWR _4082_/A sky130_fd_sc_hd__o21a_2
XFILLER_24_412 VGND VGND VPWR VPWR sky130_fd_sc_hd__fill_1
XFILLER_36_250 VGND VGND VPWR VPWR sky130_fd_sc_hd__fill_2
XFILLER_43_209 VGND VGND VPWR VPWR sky130_fd_sc_hd__decap_3
XFILLER_51_220 VGND VGND VPWR VPWR sky130_fd_sc_hd__decap_3
XFILLER_51_231 VGND VGND VPWR VPWR sky130_fd_sc_hd__fill_2
XFILLER_12_607 VGND VGND VPWR VPWR sky130_fd_sc_hd__decap_3
XFILLER_24_456 VGND VGND VPWR VPWR sky130_fd_sc_hd__fill_1
XFILLER_51_264 VGND VGND VPWR VPWR sky130_fd_sc_hd__decap_3
XFILLER_24_489 VGND VGND VPWR VPWR sky130_fd_sc_hd__decap_3
X_4968_ _4968_/A _4967_/B VGND VGND VPWR VPWR _4968_/Y sky130_fd_sc_hd__nor2b_2
XFILLER_20_640 VGND VGND VPWR VPWR sky130_fd_sc_hd__decap_3
X_6707_ _6965_/CLK _6707_/D VGND VGND VPWR VPWR _6707_/Q sky130_fd_sc_hd__dfxtp_2
X_4899_ _5061_/S _6998_/D _5656_/B _4898_/X VGND VGND VPWR VPWR _4899_/X sky130_fd_sc_hd__o22a_2
X_3919_ _3927_/A1 _3918_/X _5104_/A VGND VGND VPWR VPWR _3919_/X sky130_fd_sc_hd__a21o_2
X_6638_ _6638_/A VGND VGND VPWR VPWR _6638_/Y sky130_fd_sc_hd__inv_2
XFILLER_105_200 VGND VGND VPWR VPWR sky130_fd_sc_hd__decap_3
XFILLER_3_316 VGND VGND VPWR VPWR sky130_fd_sc_hd__decap_3
X_6569_ _6601_/A VGND VGND VPWR VPWR _6569_/Y sky130_fd_sc_hd__inv_2
XFILLER_3_349 VGND VGND VPWR VPWR sky130_fd_sc_hd__decap_3
XFILLER_79_607 VGND VGND VPWR VPWR sky130_fd_sc_hd__decap_3
XFILLER_105_266 VGND VGND VPWR VPWR sky130_fd_sc_hd__fill_2
XFILLER_78_117 VGND VGND VPWR VPWR sky130_fd_sc_hd__decap_3
Xoutput470 _5657_/B VGND VGND VPWR VPWR alu_result_out[20] sky130_fd_sc_hd__clkdlybuf4s25_1
XFILLER_105_299 VGND VGND VPWR VPWR sky130_fd_sc_hd__decap_3
Xoutput492 _5645_/X VGND VGND VPWR VPWR instruction_out[12] sky130_fd_sc_hd__clkdlybuf4s25_1
Xoutput481 _5655_/A VGND VGND VPWR VPWR alu_result_out[30] sky130_fd_sc_hd__clkdlybuf4s25_1
XFILLER_101_461 VGND VGND VPWR VPWR sky130_fd_sc_hd__decap_3
XFILLER_47_54 VGND VGND VPWR VPWR sky130_fd_sc_hd__fill_2
XFILLER_59_386 VGND VGND VPWR VPWR sky130_fd_sc_hd__decap_3
XFILLER_19_239 VGND VGND VPWR VPWR sky130_fd_sc_hd__decap_3
XFILLER_47_559 VGND VGND VPWR VPWR sky130_fd_sc_hd__fill_1
XFILLER_86_194 VGND VGND VPWR VPWR sky130_fd_sc_hd__fill_2
XFILLER_103_60 VGND VGND VPWR VPWR sky130_fd_sc_hd__fill_1
XFILLER_62_518 VGND VGND VPWR VPWR sky130_fd_sc_hd__fill_1
XFILLER_63_20 VGND VGND VPWR VPWR sky130_fd_sc_hd__decap_3
XTAP_TAPCELL_ROW_45_749 VGND VPWR sky130_fd_sc_hd__tapvpwrvgnd_1
XTAP_TAPCELL_ROW_17_429 VGND VPWR sky130_fd_sc_hd__tapvpwrvgnd_1
XFILLER_42_253 VGND VGND VPWR VPWR sky130_fd_sc_hd__fill_1
XFILLER_42_264 VGND VGND VPWR VPWR sky130_fd_sc_hd__decap_3
XFILLER_63_75 VGND VGND VPWR VPWR sky130_fd_sc_hd__fill_2
XFILLER_70_562 VGND VGND VPWR VPWR sky130_fd_sc_hd__fill_1
XPHY_EDGE_ROW_69_Right_69 VGND VGND VPWR VPWR sky130_fd_sc_hd__decap_3
XFILLER_15_489 VGND VGND VPWR VPWR sky130_fd_sc_hd__decap_3
XFILLER_30_437 VGND VGND VPWR VPWR sky130_fd_sc_hd__decap_3
XFILLER_70_584 VGND VGND VPWR VPWR sky130_fd_sc_hd__decap_3
XFILLER_70_595 VGND VGND VPWR VPWR sky130_fd_sc_hd__decap_3
XFILLER_7_600 VGND VGND VPWR VPWR sky130_fd_sc_hd__decap_3
XPHY_EDGE_ROW_7_Left_116 VGND VGND VPWR VPWR sky130_fd_sc_hd__decap_3
XFILLER_7_644 VGND VGND VPWR VPWR sky130_fd_sc_hd__decap_3
Xwire564 _3339_/Y VGND VGND VPWR VPWR _3469_/A sky130_fd_sc_hd__clkbuf_2
XTAP_TAPCELL_ROW_77_1117 VGND VPWR sky130_fd_sc_hd__tapvpwrvgnd_1
XFILLER_6_154 VGND VGND VPWR VPWR sky130_fd_sc_hd__decap_3
XFILLER_6_187 VGND VGND VPWR VPWR sky130_fd_sc_hd__decap_3
XPHY_EDGE_ROW_78_Right_78 VGND VGND VPWR VPWR sky130_fd_sc_hd__decap_3
XFILLER_97_426 VGND VGND VPWR VPWR sky130_fd_sc_hd__fill_1
XFILLER_88_94 VGND VGND VPWR VPWR sky130_fd_sc_hd__decap_3
XFILLER_77_161 VGND VGND VPWR VPWR sky130_fd_sc_hd__decap_3
XFILLER_77_172 VGND VGND VPWR VPWR sky130_fd_sc_hd__decap_3
XFILLER_93_632 VGND VGND VPWR VPWR sky130_fd_sc_hd__decap_3
XFILLER_92_131 VGND VGND VPWR VPWR sky130_fd_sc_hd__decap_3
XTAP_TAPCELL_ROW_88_1246 VGND VPWR sky130_fd_sc_hd__tapvpwrvgnd_1
XFILLER_80_315 VGND VGND VPWR VPWR sky130_fd_sc_hd__decap_3
XFILLER_92_153 VGND VGND VPWR VPWR sky130_fd_sc_hd__decap_3
XFILLER_18_272 VGND VGND VPWR VPWR sky130_fd_sc_hd__fill_1
XFILLER_46_592 VGND VGND VPWR VPWR sky130_fd_sc_hd__decap_3
XFILLER_92_197 VGND VGND VPWR VPWR sky130_fd_sc_hd__decap_3
XPHY_EDGE_ROW_87_Right_87 VGND VGND VPWR VPWR sky130_fd_sc_hd__decap_3
XFILLER_21_404 VGND VGND VPWR VPWR sky130_fd_sc_hd__decap_3
XFILLER_33_231 VGND VGND VPWR VPWR sky130_fd_sc_hd__decap_3
XFILLER_33_264 VGND VGND VPWR VPWR sky130_fd_sc_hd__decap_3
X_4822_ _5061_/S _7002_/D _5663_/B _4821_/X VGND VGND VPWR VPWR _4822_/X sky130_fd_sc_hd__o22a_2
X_4753_ _4753_/A0 _4752_/X _4946_/S VGND VGND VPWR VPWR _7276_/D sky130_fd_sc_hd__mux2_2
X_3704_ _6712_/Q _3823_/A2 _3883_/B1 _6890_/Q _3703_/X VGND VGND VPWR VPWR _3704_/X
+ sky130_fd_sc_hd__a221o_2
X_6423_ _6556_/A VGND VGND VPWR VPWR _6423_/Y sky130_fd_sc_hd__inv_2
X_4684_ _6996_/Q _4668_/X _4943_/A _4683_/X VGND VGND VPWR VPWR _4684_/X sky130_fd_sc_hd__a31o_2
XTAP_TAPCELL_ROW_99_1375 VGND VPWR sky130_fd_sc_hd__tapvpwrvgnd_1
X_3635_ _3635_/A _3635_/B _3547_/A VGND VGND VPWR VPWR _3635_/X sky130_fd_sc_hd__or3b_2
XPHY_EDGE_ROW_96_Right_96 VGND VGND VPWR VPWR sky130_fd_sc_hd__decap_3
XFILLER_108_38 VGND VGND VPWR VPWR sky130_fd_sc_hd__decap_3
X_6354_ _6680_/A VGND VGND VPWR VPWR _6354_/Y sky130_fd_sc_hd__inv_2
X_3566_ _7189_/Q _4471_/S _3380_/Y _7381_/Q VGND VGND VPWR VPWR _3566_/X sky130_fd_sc_hd__a22o_2
X_6285_ _6397_/A VGND VGND VPWR VPWR _6285_/Y sky130_fd_sc_hd__inv_2
X_3497_ _7151_/Q _3409_/X _3493_/X _3496_/X VGND VGND VPWR VPWR _3497_/X sky130_fd_sc_hd__a211o_2
XFILLER_88_448 VGND VGND VPWR VPWR sky130_fd_sc_hd__decap_3
X_5236_ _5236_/A0 _4752_/X _5274_/S VGND VGND VPWR VPWR _7212_/D sky130_fd_sc_hd__mux2_2
XFILLER_56_312 VGND VGND VPWR VPWR sky130_fd_sc_hd__decap_3
X_5167_ _5167_/A _5186_/B VGND VGND VPWR VPWR _7244_/D sky130_fd_sc_hd__and2_2
XFILLER_68_194 VGND VGND VPWR VPWR sky130_fd_sc_hd__fill_2
XFILLER_83_131 VGND VGND VPWR VPWR sky130_fd_sc_hd__decap_3
X_5098_ _5098_/A _5098_/B VGND VGND VPWR VPWR _6985_/D sky130_fd_sc_hd__nor2_2
X_4118_ _7021_/Q _4190_/A2 _4272_/B _7364_/Q VGND VGND VPWR VPWR _4118_/X sky130_fd_sc_hd__a22o_2
XFILLER_17_35 VGND VGND VPWR VPWR sky130_fd_sc_hd__decap_3
XFILLER_17_46 VGND VGND VPWR VPWR sky130_fd_sc_hd__decap_3
XFILLER_37_570 VGND VGND VPWR VPWR sky130_fd_sc_hd__decap_3
XFILLER_44_507 VGND VGND VPWR VPWR sky130_fd_sc_hd__decap_3
XFILLER_83_175 VGND VGND VPWR VPWR sky130_fd_sc_hd__decap_3
X_4049_ _7213_/Q _3943_/S _4865_/S _7309_/Q _4048_/X VGND VGND VPWR VPWR _4049_/X
+ sky130_fd_sc_hd__a221o_2
XFILLER_17_57 VGND VGND VPWR VPWR sky130_fd_sc_hd__decap_3
XFILLER_37_592 VGND VGND VPWR VPWR sky130_fd_sc_hd__decap_3
XFILLER_71_337 VGND VGND VPWR VPWR sky130_fd_sc_hd__decap_3
XTAP_TAPCELL_ROW_108_1493 VGND VPWR sky130_fd_sc_hd__tapvpwrvgnd_1
XTAP_TAPCELL_ROW_108_1482 VGND VPWR sky130_fd_sc_hd__tapvpwrvgnd_1
XTAP_TAPCELL_ROW_108_1471 VGND VPWR sky130_fd_sc_hd__tapvpwrvgnd_1
XFILLER_24_253 VGND VGND VPWR VPWR sky130_fd_sc_hd__decap_3
XTAP_TAPCELL_ROW_42_719 VGND VPWR sky130_fd_sc_hd__tapvpwrvgnd_1
XFILLER_12_426 VGND VGND VPWR VPWR sky130_fd_sc_hd__decap_3
XFILLER_24_286 VGND VGND VPWR VPWR sky130_fd_sc_hd__decap_3
XFILLER_33_78 VGND VGND VPWR VPWR sky130_fd_sc_hd__decap_3
XTAP_TAPCELL_ROW_22_487 VGND VPWR sky130_fd_sc_hd__tapvpwrvgnd_1
XFILLER_4_625 VGND VGND VPWR VPWR sky130_fd_sc_hd__decap_3
XFILLER_3_113 VGND VGND VPWR VPWR sky130_fd_sc_hd__decap_3
XPHY_EDGE_ROW_89_Left_198 VGND VGND VPWR VPWR sky130_fd_sc_hd__decap_3
XTAP_TAPCELL_ROW_72_1058 VGND VPWR sky130_fd_sc_hd__tapvpwrvgnd_1
XFILLER_58_42 VGND VGND VPWR VPWR sky130_fd_sc_hd__decap_3
XFILLER_59_150 VGND VGND VPWR VPWR sky130_fd_sc_hd__decap_3
XFILLER_59_172 VGND VGND VPWR VPWR sky130_fd_sc_hd__decap_3
XFILLER_75_610 VGND VGND VPWR VPWR sky130_fd_sc_hd__decap_3
XFILLER_87_470 VGND VGND VPWR VPWR sky130_fd_sc_hd__decap_3
XFILLER_59_194 VGND VGND VPWR VPWR sky130_fd_sc_hd__decap_3
XFILLER_47_389 VGND VGND VPWR VPWR sky130_fd_sc_hd__decap_3
XFILLER_74_153 VGND VGND VPWR VPWR sky130_fd_sc_hd__decap_3
XFILLER_15_220 VGND VGND VPWR VPWR sky130_fd_sc_hd__decap_3
XFILLER_28_592 VGND VGND VPWR VPWR sky130_fd_sc_hd__decap_3
XFILLER_74_197 VGND VGND VPWR VPWR sky130_fd_sc_hd__decap_3
XTAP_TAPCELL_ROW_58_896 VGND VPWR sky130_fd_sc_hd__tapvpwrvgnd_1
XFILLER_15_242 VGND VGND VPWR VPWR sky130_fd_sc_hd__fill_1
XFILLER_30_212 VGND VGND VPWR VPWR sky130_fd_sc_hd__decap_3
XFILLER_43_573 VGND VGND VPWR VPWR sky130_fd_sc_hd__decap_3
XTAP_TAPCELL_ROW_83_1187 VGND VPWR sky130_fd_sc_hd__tapvpwrvgnd_1
XFILLER_70_392 VGND VGND VPWR VPWR sky130_fd_sc_hd__decap_3
XFILLER_30_256 VGND VGND VPWR VPWR sky130_fd_sc_hd__decap_3
XFILLER_11_470 VGND VGND VPWR VPWR sky130_fd_sc_hd__decap_3
XFILLER_7_452 VGND VGND VPWR VPWR sky130_fd_sc_hd__fill_1
X_3420_ _3420_/A _5642_/B VGND VGND VPWR VPWR _3442_/B sky130_fd_sc_hd__or2_2
X_3351_ _5130_/A _3350_/Y _3340_/B VGND VGND VPWR VPWR _5642_/B sky130_fd_sc_hd__o21a_2
XFILLER_31_3 VGND VGND VPWR VPWR sky130_fd_sc_hd__decap_3
XFILLER_97_234 VGND VGND VPWR VPWR sky130_fd_sc_hd__decap_3
XFILLER_38_312 VGND VGND VPWR VPWR sky130_fd_sc_hd__decap_3
XFILLER_66_610 VGND VGND VPWR VPWR sky130_fd_sc_hd__decap_3
XFILLER_85_418 VGND VGND VPWR VPWR sky130_fd_sc_hd__decap_3
Xhold1108 _7316_/Q VGND VGND VPWR VPWR _4526_/A0 sky130_fd_sc_hd__dlygate4sd3_1
Xhold1119 _7160_/Q VGND VGND VPWR VPWR _5342_/A0 sky130_fd_sc_hd__dlygate4sd3_1
X_5021_ _5072_/A _4372_/A _5018_/A _5101_/A VGND VGND VPWR VPWR _5021_/X sky130_fd_sc_hd__o2bb2a_2
XFILLER_38_334 VGND VGND VPWR VPWR sky130_fd_sc_hd__fill_1
XFILLER_66_643 VGND VGND VPWR VPWR sky130_fd_sc_hd__fill_1
XFILLER_38_378 VGND VGND VPWR VPWR sky130_fd_sc_hd__fill_1
XFILLER_65_142 VGND VGND VPWR VPWR sky130_fd_sc_hd__decap_3
XFILLER_65_175 VGND VGND VPWR VPWR sky130_fd_sc_hd__fill_1
XFILLER_80_112 VGND VGND VPWR VPWR sky130_fd_sc_hd__decap_3
X_6972_ clkload5/A _6972_/D VGND VGND VPWR VPWR _6972_/Q sky130_fd_sc_hd__dfxtp_2
XFILLER_21_201 VGND VGND VPWR VPWR sky130_fd_sc_hd__decap_3
XFILLER_34_573 VGND VGND VPWR VPWR sky130_fd_sc_hd__decap_3
XFILLER_61_370 VGND VGND VPWR VPWR sky130_fd_sc_hd__decap_3
XFILLER_80_178 VGND VGND VPWR VPWR sky130_fd_sc_hd__decap_3
X_4805_ _4878_/A1 _7003_/D _4804_/X VGND VGND VPWR VPWR _4805_/X sky130_fd_sc_hd__a21bo_2
XFILLER_21_256 VGND VGND VPWR VPWR sky130_fd_sc_hd__fill_1
XFILLER_107_306 VGND VGND VPWR VPWR sky130_fd_sc_hd__fill_1
X_4667_ _6998_/Q _4667_/B VGND VGND VPWR VPWR _4896_/A sky130_fd_sc_hd__xnor2_2
XFILLER_102_9 VGND VGND VPWR VPWR sky130_fd_sc_hd__decap_3
X_7386_ _7398_/CLK _7386_/D _6666_/Y VGND VGND VPWR VPWR _7386_/Q sky130_fd_sc_hd__dfrtp_2
Xhold920 _6701_/Q VGND VGND VPWR VPWR hold920/X sky130_fd_sc_hd__dlygate4sd3_1
Xhold931 _7028_/Q VGND VGND VPWR VPWR hold931/X sky130_fd_sc_hd__dlygate4sd3_1
X_6406_ _6632_/A VGND VGND VPWR VPWR _6406_/Y sky130_fd_sc_hd__inv_2
X_3618_ _5118_/C _4938_/A _3618_/C VGND VGND VPWR VPWR _3618_/X sky130_fd_sc_hd__and3_2
XFILLER_1_617 VGND VGND VPWR VPWR sky130_fd_sc_hd__decap_3
Xhold964 _7054_/Q VGND VGND VPWR VPWR hold964/X sky130_fd_sc_hd__dlygate4sd3_1
Xhold953 _7052_/Q VGND VGND VPWR VPWR hold953/X sky130_fd_sc_hd__dlygate4sd3_1
Xhold942 _7041_/Q VGND VGND VPWR VPWR hold942/X sky130_fd_sc_hd__dlygate4sd3_1
X_6337_ _6463_/A VGND VGND VPWR VPWR _6337_/Y sky130_fd_sc_hd__inv_2
XFILLER_0_116 VGND VGND VPWR VPWR sky130_fd_sc_hd__fill_2
XFILLER_103_523 VGND VGND VPWR VPWR sky130_fd_sc_hd__fill_2
XFILLER_88_223 VGND VGND VPWR VPWR sky130_fd_sc_hd__decap_3
Xhold997 _7196_/Q VGND VGND VPWR VPWR hold997/X sky130_fd_sc_hd__dlygate4sd3_1
Xhold986 _7401_/Q VGND VGND VPWR VPWR hold986/X sky130_fd_sc_hd__dlygate4sd3_1
Xhold975 _7022_/Q VGND VGND VPWR VPWR _5611_/A sky130_fd_sc_hd__dlygate4sd3_1
XFILLER_0_138 VGND VGND VPWR VPWR sky130_fd_sc_hd__fill_2
XFILLER_0_149 VGND VGND VPWR VPWR sky130_fd_sc_hd__decap_3
XFILLER_103_567 VGND VGND VPWR VPWR sky130_fd_sc_hd__decap_3
XFILLER_76_407 VGND VGND VPWR VPWR sky130_fd_sc_hd__decap_3
XFILLER_88_256 VGND VGND VPWR VPWR sky130_fd_sc_hd__decap_3
X_6268_ _6684_/A VGND VGND VPWR VPWR _6268_/Y sky130_fd_sc_hd__inv_2
X_5219_ _5219_/A _5225_/B VGND VGND VPWR VPWR _7219_/D sky130_fd_sc_hd__and2_2
XFILLER_29_323 VGND VGND VPWR VPWR sky130_fd_sc_hd__decap_3
XFILLER_56_120 VGND VGND VPWR VPWR sky130_fd_sc_hd__decap_3
XFILLER_57_632 VGND VGND VPWR VPWR sky130_fd_sc_hd__decap_3
XFILLER_17_529 VGND VGND VPWR VPWR sky130_fd_sc_hd__decap_3
XFILLER_44_304 VGND VGND VPWR VPWR sky130_fd_sc_hd__decap_3
XFILLER_56_153 VGND VGND VPWR VPWR sky130_fd_sc_hd__fill_2
XFILLER_84_473 VGND VGND VPWR VPWR sky130_fd_sc_hd__decap_3
XFILLER_71_134 VGND VGND VPWR VPWR sky130_fd_sc_hd__decap_3
XFILLER_71_167 VGND VGND VPWR VPWR sky130_fd_sc_hd__fill_1
XTAP_TAPCELL_ROW_55_866 VGND VPWR sky130_fd_sc_hd__tapvpwrvgnd_1
XTAP_TAPCELL_ROW_27_546 VGND VPWR sky130_fd_sc_hd__tapvpwrvgnd_1
XFILLER_12_212 VGND VGND VPWR VPWR sky130_fd_sc_hd__decap_3
XFILLER_44_55 VGND VGND VPWR VPWR sky130_fd_sc_hd__decap_3
XFILLER_71_178 VGND VGND VPWR VPWR sky130_fd_sc_hd__decap_3
XFILLER_12_245 VGND VGND VPWR VPWR sky130_fd_sc_hd__decap_3
XFILLER_44_88 VGND VGND VPWR VPWR sky130_fd_sc_hd__decap_3
XFILLER_12_256 VGND VGND VPWR VPWR sky130_fd_sc_hd__decap_3
XFILLER_12_278 VGND VGND VPWR VPWR sky130_fd_sc_hd__decap_3
XFILLER_8_227 VGND VGND VPWR VPWR sky130_fd_sc_hd__decap_3
XFILLER_100_83 VGND VGND VPWR VPWR sky130_fd_sc_hd__fill_1
XFILLER_60_32 VGND VGND VPWR VPWR sky130_fd_sc_hd__fill_2
XFILLER_60_54 VGND VGND VPWR VPWR sky130_fd_sc_hd__decap_3
XFILLER_60_76 VGND VGND VPWR VPWR sky130_fd_sc_hd__decap_3
XPHY_EDGE_ROW_97_Left_206 VGND VGND VPWR VPWR sky130_fd_sc_hd__decap_3
XFILLER_4_477 VGND VGND VPWR VPWR sky130_fd_sc_hd__decap_3
XFILLER_106_383 VGND VGND VPWR VPWR sky130_fd_sc_hd__decap_3
XFILLER_79_223 VGND VGND VPWR VPWR sky130_fd_sc_hd__fill_1
XFILLER_79_256 VGND VGND VPWR VPWR sky130_fd_sc_hd__decap_3
XFILLER_39_109 VGND VGND VPWR VPWR sky130_fd_sc_hd__decap_3
XFILLER_79_278 VGND VGND VPWR VPWR sky130_fd_sc_hd__fill_2
XFILLER_94_204 VGND VGND VPWR VPWR sky130_fd_sc_hd__fill_1
XFILLER_47_131 VGND VGND VPWR VPWR sky130_fd_sc_hd__decap_3
XFILLER_48_643 VGND VGND VPWR VPWR sky130_fd_sc_hd__fill_1
XFILLER_94_259 VGND VGND VPWR VPWR sky130_fd_sc_hd__fill_1
XFILLER_47_164 VGND VGND VPWR VPWR sky130_fd_sc_hd__decap_3
XFILLER_63_613 VGND VGND VPWR VPWR sky130_fd_sc_hd__decap_3
XFILLER_85_95 VGND VGND VPWR VPWR sky130_fd_sc_hd__decap_3
XFILLER_35_337 VGND VGND VPWR VPWR sky130_fd_sc_hd__fill_2
XFILLER_47_175 VGND VGND VPWR VPWR sky130_fd_sc_hd__fill_1
XFILLER_47_186 VGND VGND VPWR VPWR sky130_fd_sc_hd__decap_3
XFILLER_62_101 VGND VGND VPWR VPWR sky130_fd_sc_hd__decap_3
XFILLER_63_635 VGND VGND VPWR VPWR sky130_fd_sc_hd__decap_3
XFILLER_75_495 VGND VGND VPWR VPWR sky130_fd_sc_hd__decap_3
XFILLER_90_421 VGND VGND VPWR VPWR sky130_fd_sc_hd__fill_2
XFILLER_90_432 VGND VGND VPWR VPWR sky130_fd_sc_hd__decap_3
XTAP_TAPCELL_ROW_85_1216 VGND VPWR sky130_fd_sc_hd__tapvpwrvgnd_1
XFILLER_35_348 VGND VGND VPWR VPWR sky130_fd_sc_hd__fill_2
XFILLER_90_465 VGND VGND VPWR VPWR sky130_fd_sc_hd__decap_3
XFILLER_50_307 VGND VGND VPWR VPWR sky130_fd_sc_hd__fill_1
XFILLER_50_329 VGND VGND VPWR VPWR sky130_fd_sc_hd__decap_3
XFILLER_62_167 VGND VGND VPWR VPWR sky130_fd_sc_hd__decap_3
XFILLER_16_595 VGND VGND VPWR VPWR sky130_fd_sc_hd__decap_3
XFILLER_31_598 VGND VGND VPWR VPWR sky130_fd_sc_hd__decap_3
X_5570_ hold980/X _4983_/A _4929_/Y VGND VGND VPWR VPWR _7047_/D sky130_fd_sc_hd__o21a_2
XTAP_TAPCELL_ROW_96_1334 VGND VPWR sky130_fd_sc_hd__tapvpwrvgnd_1
X_7240_ _7374_/CLK _7240_/D _6520_/Y VGND VGND VPWR VPWR _7240_/Q sky130_fd_sc_hd__dfrtp_2
X_4452_ _4452_/A _4765_/B VGND VGND VPWR VPWR _4453_/A sky130_fd_sc_hd__or2_2
XFILLER_104_309 VGND VGND VPWR VPWR sky130_fd_sc_hd__decap_3
X_3403_ _6979_/Q _4467_/B VGND VGND VPWR VPWR _4667_/B sky130_fd_sc_hd__or2_4
X_7171_ _7363_/CLK _7171_/D _6451_/Y VGND VGND VPWR VPWR _7171_/Q sky130_fd_sc_hd__dfrtp_2
X_4383_ _4920_/A _4937_/A _4383_/C VGND VGND VPWR VPWR _4384_/C sky130_fd_sc_hd__and3_2
X_3334_ _3330_/Y _3528_/A _5156_/S VGND VGND VPWR VPWR _3334_/Y sky130_fd_sc_hd__o21ai_2
XFILLER_105_17 VGND VGND VPWR VPWR sky130_fd_sc_hd__decap_3
XFILLER_98_598 VGND VGND VPWR VPWR sky130_fd_sc_hd__decap_3
XFILLER_100_548 VGND VGND VPWR VPWR sky130_fd_sc_hd__fill_2
XFILLER_39_632 VGND VGND VPWR VPWR sky130_fd_sc_hd__decap_3
XFILLER_85_237 VGND VGND VPWR VPWR sky130_fd_sc_hd__decap_3
XFILLER_85_259 VGND VGND VPWR VPWR sky130_fd_sc_hd__decap_3
X_5004_ _5004_/A _5004_/B VGND VGND VPWR VPWR _5004_/X sky130_fd_sc_hd__or2_2
XFILLER_38_153 VGND VGND VPWR VPWR sky130_fd_sc_hd__fill_1
XFILLER_38_164 VGND VGND VPWR VPWR sky130_fd_sc_hd__decap_3
XFILLER_54_602 VGND VGND VPWR VPWR sky130_fd_sc_hd__decap_3
XFILLER_66_462 VGND VGND VPWR VPWR sky130_fd_sc_hd__decap_3
XFILLER_26_315 VGND VGND VPWR VPWR sky130_fd_sc_hd__decap_3
XFILLER_38_197 VGND VGND VPWR VPWR sky130_fd_sc_hd__fill_2
XFILLER_54_635 VGND VGND VPWR VPWR sky130_fd_sc_hd__decap_3
XFILLER_81_421 VGND VGND VPWR VPWR sky130_fd_sc_hd__decap_3
XFILLER_93_281 VGND VGND VPWR VPWR sky130_fd_sc_hd__decap_3
XFILLER_53_156 VGND VGND VPWR VPWR sky130_fd_sc_hd__decap_3
X_6955_ clkload6/A _6955_/D VGND VGND VPWR VPWR _6955_/Q sky130_fd_sc_hd__dfxtp_2
XFILLER_41_329 VGND VGND VPWR VPWR sky130_fd_sc_hd__decap_3
XFILLER_53_178 VGND VGND VPWR VPWR sky130_fd_sc_hd__decap_3
XFILLER_81_476 VGND VGND VPWR VPWR sky130_fd_sc_hd__decap_3
XTAP_TAPCELL_ROW_52_836 VGND VPWR sky130_fd_sc_hd__tapvpwrvgnd_1
XTAP_TAPCELL_ROW_24_516 VGND VPWR sky130_fd_sc_hd__tapvpwrvgnd_1
XTAP_TAPCELL_ROW_24_505 VGND VPWR sky130_fd_sc_hd__tapvpwrvgnd_1
XTAP_TAPCELL_ROW_105_1441 VGND VPWR sky130_fd_sc_hd__tapvpwrvgnd_1
X_6886_ _6965_/CLK _6886_/D VGND VGND VPWR VPWR _6886_/Q sky130_fd_sc_hd__dfxtp_2
XFILLER_22_598 VGND VGND VPWR VPWR sky130_fd_sc_hd__decap_3
X_5699_ _7355_/Q _6699_/Q _5708_/S VGND VGND VPWR VPWR _6699_/D sky130_fd_sc_hd__mux2_2
XFILLER_107_169 VGND VGND VPWR VPWR sky130_fd_sc_hd__decap_3
XFILLER_30_79 VGND VGND VPWR VPWR sky130_fd_sc_hd__decap_3
XFILLER_1_403 VGND VGND VPWR VPWR sky130_fd_sc_hd__fill_2
X_7369_ _7406_/CLK _7369_/D _6649_/Y VGND VGND VPWR VPWR _7369_/Q sky130_fd_sc_hd__dfrtp_2
Xhold750 _6953_/Q VGND VGND VPWR VPWR _6953_/D sky130_fd_sc_hd__dlygate4sd3_1
Xhold761 _6923_/Q VGND VGND VPWR VPWR _6923_/D sky130_fd_sc_hd__dlygate4sd3_1
Xhold772 _6909_/Q VGND VGND VPWR VPWR _6909_/D sky130_fd_sc_hd__dlygate4sd3_1
XFILLER_89_554 VGND VGND VPWR VPWR sky130_fd_sc_hd__decap_3
Xhold783 _6760_/Q VGND VGND VPWR VPWR _6760_/D sky130_fd_sc_hd__dlygate4sd3_1
Xhold794 _6849_/Q VGND VGND VPWR VPWR _6849_/D sky130_fd_sc_hd__dlygate4sd3_1
XFILLER_103_364 VGND VGND VPWR VPWR sky130_fd_sc_hd__decap_3
XFILLER_39_66 VGND VGND VPWR VPWR sky130_fd_sc_hd__decap_3
XFILLER_76_215 VGND VGND VPWR VPWR sky130_fd_sc_hd__decap_3
XFILLER_39_99 VGND VGND VPWR VPWR sky130_fd_sc_hd__fill_2
XFILLER_76_259 VGND VGND VPWR VPWR sky130_fd_sc_hd__decap_3
XFILLER_17_304 VGND VGND VPWR VPWR sky130_fd_sc_hd__decap_3
XFILLER_45_613 VGND VGND VPWR VPWR sky130_fd_sc_hd__decap_3
XFILLER_57_462 VGND VGND VPWR VPWR sky130_fd_sc_hd__decap_3
XFILLER_91_218 VGND VGND VPWR VPWR sky130_fd_sc_hd__fill_1
XTAP_TAPCELL_ROW_4_285 VGND VPWR sky130_fd_sc_hd__tapvpwrvgnd_1
XFILLER_29_175 VGND VGND VPWR VPWR sky130_fd_sc_hd__decap_3
XFILLER_45_635 VGND VGND VPWR VPWR sky130_fd_sc_hd__decap_3
XFILLER_72_410 VGND VGND VPWR VPWR sky130_fd_sc_hd__fill_1
XFILLER_72_421 VGND VGND VPWR VPWR sky130_fd_sc_hd__decap_3
XFILLER_44_156 VGND VGND VPWR VPWR sky130_fd_sc_hd__decap_3
XFILLER_32_329 VGND VGND VPWR VPWR sky130_fd_sc_hd__decap_3
XFILLER_60_627 VGND VGND VPWR VPWR sky130_fd_sc_hd__decap_3
XPHY_EDGE_ROW_105_Right_105 VGND VGND VPWR VPWR sky130_fd_sc_hd__decap_3
XFILLER_13_576 VGND VGND VPWR VPWR sky130_fd_sc_hd__decap_3
XFILLER_40_362 VGND VGND VPWR VPWR sky130_fd_sc_hd__fill_2
XTAP_TAPCELL_ROW_80_1157 VGND VPWR sky130_fd_sc_hd__tapvpwrvgnd_1
XFILLER_9_503 VGND VGND VPWR VPWR sky130_fd_sc_hd__fill_1
XFILLER_4_285 VGND VGND VPWR VPWR sky130_fd_sc_hd__decap_3
XTAP_TAPCELL_ROW_91_1286 VGND VPWR sky130_fd_sc_hd__tapvpwrvgnd_1
XFILLER_95_502 VGND VGND VPWR VPWR sky130_fd_sc_hd__fill_2
XFILLER_0_480 VGND VGND VPWR VPWR sky130_fd_sc_hd__decap_3
XFILLER_96_83 VGND VGND VPWR VPWR sky130_fd_sc_hd__fill_1
XFILLER_95_557 VGND VGND VPWR VPWR sky130_fd_sc_hd__decap_3
XFILLER_36_635 VGND VGND VPWR VPWR sky130_fd_sc_hd__decap_3
XFILLER_75_281 VGND VGND VPWR VPWR sky130_fd_sc_hd__decap_3
XFILLER_35_145 VGND VGND VPWR VPWR sky130_fd_sc_hd__fill_2
XFILLER_51_605 VGND VGND VPWR VPWR sky130_fd_sc_hd__decap_3
XFILLER_75_292 VGND VGND VPWR VPWR sky130_fd_sc_hd__decap_3
Xplace410 _4399_/A2 VGND VGND VPWR VPWR _4437_/B1 sky130_fd_sc_hd__buf_2
Xplace421 _4471_/S VGND VGND VPWR VPWR _3966_/S sky130_fd_sc_hd__buf_2
XFILLER_51_638 VGND VGND VPWR VPWR sky130_fd_sc_hd__decap_3
XFILLER_90_251 VGND VGND VPWR VPWR sky130_fd_sc_hd__fill_1
Xplace432 _3344_/Y VGND VGND VPWR VPWR _4677_/B sky130_fd_sc_hd__buf_2
Xplace443 _4307_/A2 VGND VGND VPWR VPWR _4353_/A2 sky130_fd_sc_hd__buf_2
Xplace454 _6980_/Q VGND VGND VPWR VPWR _3365_/A sky130_fd_sc_hd__buf_2
X_6740_ clkload8/A _6740_/D VGND VGND VPWR VPWR _6740_/Q sky130_fd_sc_hd__dfxtp_2
X_3952_ _7364_/Q _4495_/A0 _3958_/S VGND VGND VPWR VPWR _7364_/D sky130_fd_sc_hd__mux2_2
XFILLER_31_340 VGND VGND VPWR VPWR sky130_fd_sc_hd__decap_3
XFILLER_50_159 VGND VGND VPWR VPWR sky130_fd_sc_hd__decap_3
X_6671_ _6678_/A VGND VGND VPWR VPWR _6671_/Y sky130_fd_sc_hd__inv_2
X_3883_ _6814_/Q _3883_/A2 _3883_/B1 _6819_/Q VGND VGND VPWR VPWR _3883_/X sky130_fd_sc_hd__a22o_2
XFILLER_31_373 VGND VGND VPWR VPWR sky130_fd_sc_hd__decap_3
X_5622_ _5622_/A _5622_/B VGND VGND VPWR VPWR _7017_/D sky130_fd_sc_hd__nor2_2
XTAP_TAPCELL_ROW_100_1382 VGND VPWR sky130_fd_sc_hd__tapvpwrvgnd_1
XFILLER_105_629 VGND VGND VPWR VPWR sky130_fd_sc_hd__decap_3
X_7223_ _7280_/CLK _7223_/D _6503_/Y VGND VGND VPWR VPWR _7223_/Q sky130_fd_sc_hd__dfrtp_2
X_4435_ _7207_/Q _3945_/S _4394_/B _7367_/Q VGND VGND VPWR VPWR _4435_/X sky130_fd_sc_hd__a22o_2
X_7154_ _7355_/CLK _7154_/D _6434_/Y VGND VGND VPWR VPWR _7154_/Q sky130_fd_sc_hd__dfrtp_2
X_4366_ _4460_/A _4364_/Y _4313_/D _4361_/A _4365_/X VGND VGND VPWR VPWR _4366_/X
+ sky130_fd_sc_hd__a32o_2
XFILLER_100_312 VGND VGND VPWR VPWR sky130_fd_sc_hd__decap_3
XFILLER_100_334 VGND VGND VPWR VPWR sky130_fd_sc_hd__decap_3
X_7085_ _7405_/CLK _7085_/D _6365_/Y VGND VGND VPWR VPWR _7085_/Q sky130_fd_sc_hd__dfrtp_2
X_4297_ _5113_/A _4297_/B VGND VGND VPWR VPWR _4297_/Y sky130_fd_sc_hd__nor2_2
XFILLER_98_395 VGND VGND VPWR VPWR sky130_fd_sc_hd__decap_3
XFILLER_58_259 VGND VGND VPWR VPWR sky130_fd_sc_hd__decap_3
XFILLER_73_207 VGND VGND VPWR VPWR sky130_fd_sc_hd__decap_3
XFILLER_86_579 VGND VGND VPWR VPWR sky130_fd_sc_hd__decap_3
XFILLER_27_635 VGND VGND VPWR VPWR sky130_fd_sc_hd__decap_3
XFILLER_39_484 VGND VGND VPWR VPWR sky130_fd_sc_hd__decap_3
XFILLER_39_495 VGND VGND VPWR VPWR sky130_fd_sc_hd__decap_3
XFILLER_54_421 VGND VGND VPWR VPWR sky130_fd_sc_hd__fill_1
XFILLER_26_123 VGND VGND VPWR VPWR sky130_fd_sc_hd__decap_3
XTAP_TAPCELL_ROW_1_244 VGND VPWR sky130_fd_sc_hd__tapvpwrvgnd_1
XFILLER_14_307 VGND VGND VPWR VPWR sky130_fd_sc_hd__fill_1
XFILLER_26_189 VGND VGND VPWR VPWR sky130_fd_sc_hd__decap_3
XFILLER_42_627 VGND VGND VPWR VPWR sky130_fd_sc_hd__decap_3
XTAP_TAPCELL_ROW_65_983 VGND VPWR sky130_fd_sc_hd__tapvpwrvgnd_1
XTAP_TAPCELL_ROW_37_663 VGND VPWR sky130_fd_sc_hd__tapvpwrvgnd_1
XFILLER_25_46 VGND VGND VPWR VPWR sky130_fd_sc_hd__fill_2
XFILLER_25_57 VGND VGND VPWR VPWR sky130_fd_sc_hd__fill_1
XFILLER_81_284 VGND VGND VPWR VPWR sky130_fd_sc_hd__fill_1
X_6938_ _6943_/CLK _6938_/D VGND VGND VPWR VPWR _6938_/Q sky130_fd_sc_hd__dfxtp_2
X_6869_ clkload3/A _6869_/D VGND VGND VPWR VPWR _6869_/Q sky130_fd_sc_hd__dfxtp_2
XTAP_TAPCELL_ROW_9_333 VGND VPWR sky130_fd_sc_hd__tapvpwrvgnd_1
Xhold580 _6808_/Q VGND VGND VPWR VPWR _6808_/D sky130_fd_sc_hd__dlygate4sd3_1
XFILLER_1_277 VGND VGND VPWR VPWR sky130_fd_sc_hd__decap_3
XFILLER_77_502 VGND VGND VPWR VPWR sky130_fd_sc_hd__fill_2
Xhold591 _6830_/Q VGND VGND VPWR VPWR _6830_/D sky130_fd_sc_hd__dlygate4sd3_1
XFILLER_103_172 VGND VGND VPWR VPWR sky130_fd_sc_hd__decap_3
XFILLER_103_194 VGND VGND VPWR VPWR sky130_fd_sc_hd__decap_3
XFILLER_106_71 VGND VGND VPWR VPWR sky130_fd_sc_hd__decap_3
XFILLER_49_215 VGND VGND VPWR VPWR sky130_fd_sc_hd__decap_3
XFILLER_18_613 VGND VGND VPWR VPWR sky130_fd_sc_hd__decap_3
XFILLER_57_281 VGND VGND VPWR VPWR sky130_fd_sc_hd__fill_1
XFILLER_85_590 VGND VGND VPWR VPWR sky130_fd_sc_hd__decap_3
XFILLER_17_134 VGND VGND VPWR VPWR sky130_fd_sc_hd__decap_3
XFILLER_60_413 VGND VGND VPWR VPWR sky130_fd_sc_hd__decap_3
XFILLER_17_189 VGND VGND VPWR VPWR sky130_fd_sc_hd__decap_3
XFILLER_32_126 VGND VGND VPWR VPWR sky130_fd_sc_hd__decap_3
XFILLER_33_638 VGND VGND VPWR VPWR sky130_fd_sc_hd__decap_3
XFILLER_60_424 VGND VGND VPWR VPWR sky130_fd_sc_hd__decap_3
XFILLER_60_446 VGND VGND VPWR VPWR sky130_fd_sc_hd__decap_3
XFILLER_72_284 VGND VGND VPWR VPWR sky130_fd_sc_hd__decap_3
XFILLER_60_468 VGND VGND VPWR VPWR sky130_fd_sc_hd__fill_2
XFILLER_9_377 VGND VGND VPWR VPWR sky130_fd_sc_hd__decap_3
XFILLER_9_355 VGND VGND VPWR VPWR sky130_fd_sc_hd__decap_3
XFILLER_9_399 VGND VGND VPWR VPWR sky130_fd_sc_hd__decap_3
XFILLER_5_550 VGND VGND VPWR VPWR sky130_fd_sc_hd__decap_3
XTAP_TAPCELL_ROW_93_1304 VGND VPWR sky130_fd_sc_hd__tapvpwrvgnd_1
XFILLER_5_561 VGND VGND VPWR VPWR sky130_fd_sc_hd__decap_3
XFILLER_5_594 VGND VGND VPWR VPWR sky130_fd_sc_hd__decap_3
X_4220_ _7196_/Q _3966_/S _4354_/B1 _7388_/Q VGND VGND VPWR VPWR _4220_/X sky130_fd_sc_hd__a22o_2
XFILLER_99_137 VGND VGND VPWR VPWR sky130_fd_sc_hd__decap_3
XFILLER_101_109 VGND VGND VPWR VPWR sky130_fd_sc_hd__decap_3
XFILLER_68_513 VGND VGND VPWR VPWR sky130_fd_sc_hd__fill_1
X_4151_ _7019_/Q _4190_/A2 _3966_/S _7202_/Q _4150_/X VGND VGND VPWR VPWR _4151_/X
+ sky130_fd_sc_hd__a221o_2
XFILLER_83_505 VGND VGND VPWR VPWR sky130_fd_sc_hd__decap_3
XFILLER_95_343 VGND VGND VPWR VPWR sky130_fd_sc_hd__decap_3
XFILLER_95_376 VGND VGND VPWR VPWR sky130_fd_sc_hd__fill_2
X_4082_ _4082_/A _4068_/A VGND VGND VPWR VPWR _4082_/X sky130_fd_sc_hd__or2b_2
XFILLER_83_549 VGND VGND VPWR VPWR sky130_fd_sc_hd__decap_3
XFILLER_95_387 VGND VGND VPWR VPWR sky130_fd_sc_hd__decap_3
XFILLER_102_18 VGND VGND VPWR VPWR sky130_fd_sc_hd__decap_3
XFILLER_102_29 VGND VGND VPWR VPWR sky130_fd_sc_hd__decap_3
XFILLER_24_616 VGND VGND VPWR VPWR sky130_fd_sc_hd__decap_3
XFILLER_51_413 VGND VGND VPWR VPWR sky130_fd_sc_hd__decap_3
XFILLER_23_126 VGND VGND VPWR VPWR sky130_fd_sc_hd__decap_3
XFILLER_63_295 VGND VGND VPWR VPWR sky130_fd_sc_hd__decap_3
Xplace273 _3852_/B1 VGND VGND VPWR VPWR _3925_/B1 sky130_fd_sc_hd__buf_2
X_4984_ _5099_/A _4619_/Y _4624_/A VGND VGND VPWR VPWR _5031_/B sky130_fd_sc_hd__a21o_2
XTAP_TAPCELL_ROW_62_942 VGND VPWR sky130_fd_sc_hd__tapvpwrvgnd_1
XTAP_TAPCELL_ROW_34_622 VGND VPWR sky130_fd_sc_hd__tapvpwrvgnd_1
XTAP_TAPCELL_ROW_102_1411 VGND VPWR sky130_fd_sc_hd__tapvpwrvgnd_1
XFILLER_23_159 VGND VGND VPWR VPWR sky130_fd_sc_hd__decap_3
XFILLER_51_457 VGND VGND VPWR VPWR sky130_fd_sc_hd__fill_1
Xplace295 _3651_/Y VGND VGND VPWR VPWR _3926_/B1 sky130_fd_sc_hd__buf_2
Xplace284 _3913_/B1 VGND VGND VPWR VPWR _3884_/B1 sky130_fd_sc_hd__buf_2
X_6723_ _6963_/CLK _6723_/D VGND VGND VPWR VPWR _6723_/Q sky130_fd_sc_hd__dfxtp_2
X_3935_ _7372_/Q _7340_/Q _3939_/S VGND VGND VPWR VPWR _7372_/D sky130_fd_sc_hd__mux2_2
XTAP_TAPCELL_ROW_62_953 VGND VPWR sky130_fd_sc_hd__tapvpwrvgnd_1
X_6654_ _6654_/A VGND VGND VPWR VPWR _6654_/Y sky130_fd_sc_hd__inv_2
X_5605_ _5605_/A _5633_/B VGND VGND VPWR VPWR _7025_/D sky130_fd_sc_hd__or2_2
X_3866_ _6696_/Q _6786_/Q _6874_/Q _6922_/Q _3991_/B _3665_/B VGND VGND VPWR VPWR
+ _3866_/X sky130_fd_sc_hd__mux4_2
XTAP_TAPCELL_ROW_14_390 VGND VPWR sky130_fd_sc_hd__tapvpwrvgnd_1
X_6585_ _6619_/A VGND VGND VPWR VPWR _6585_/Y sky130_fd_sc_hd__inv_2
X_3797_ _6750_/Q _3888_/A2 _3893_/B1 _6732_/Q VGND VGND VPWR VPWR _3797_/X sky130_fd_sc_hd__a22o_2
XFILLER_105_426 VGND VGND VPWR VPWR sky130_fd_sc_hd__fill_1
X_7206_ _7269_/CLK _7206_/D _6486_/Y VGND VGND VPWR VPWR _7206_/Q sky130_fd_sc_hd__dfrtp_2
X_4418_ _7023_/Q _4422_/A2 _4417_/X VGND VGND VPWR VPWR _4425_/C sky130_fd_sc_hd__a21o_2
XFILLER_59_502 VGND VGND VPWR VPWR sky130_fd_sc_hd__fill_2
XFILLER_59_513 VGND VGND VPWR VPWR sky130_fd_sc_hd__decap_3
X_5398_ _5398_/A0 _4997_/X _5400_/S VGND VGND VPWR VPWR _7134_/D sky130_fd_sc_hd__mux2_2
XTAP_TAPCELL_ROW_6_303 VGND VPWR sky130_fd_sc_hd__tapvpwrvgnd_1
XFILLER_101_632 VGND VGND VPWR VPWR sky130_fd_sc_hd__decap_3
X_7137_ _7362_/CLK _7137_/D _6417_/Y VGND VGND VPWR VPWR _7137_/Q sky130_fd_sc_hd__dfrtp_2
X_4349_ _7257_/Q _4601_/S _4349_/B1 _7225_/Q _4348_/X VGND VGND VPWR VPWR _4367_/A
+ sky130_fd_sc_hd__a221o_2
XFILLER_100_131 VGND VGND VPWR VPWR sky130_fd_sc_hd__fill_1
X_7068_ _7398_/CLK _7068_/D _6348_/Y VGND VGND VPWR VPWR _7068_/Q sky130_fd_sc_hd__dfrtp_2
XFILLER_100_164 VGND VGND VPWR VPWR sky130_fd_sc_hd__decap_3
XFILLER_39_270 VGND VGND VPWR VPWR sky130_fd_sc_hd__fill_2
XFILLER_100_197 VGND VGND VPWR VPWR sky130_fd_sc_hd__decap_3
XFILLER_27_421 VGND VGND VPWR VPWR sky130_fd_sc_hd__decap_3
XFILLER_27_432 VGND VGND VPWR VPWR sky130_fd_sc_hd__decap_3
XFILLER_27_443 VGND VGND VPWR VPWR sky130_fd_sc_hd__fill_2
XFILLER_36_45 VGND VGND VPWR VPWR sky130_fd_sc_hd__decap_3
XFILLER_39_281 VGND VGND VPWR VPWR sky130_fd_sc_hd__decap_3
XFILLER_36_78 VGND VGND VPWR VPWR sky130_fd_sc_hd__decap_3
XFILLER_54_251 VGND VGND VPWR VPWR sky130_fd_sc_hd__fill_1
XFILLER_82_571 VGND VGND VPWR VPWR sky130_fd_sc_hd__decap_3
XFILLER_14_115 VGND VGND VPWR VPWR sky130_fd_sc_hd__decap_3
XFILLER_15_638 VGND VGND VPWR VPWR sky130_fd_sc_hd__decap_3
XFILLER_54_273 VGND VGND VPWR VPWR sky130_fd_sc_hd__decap_3
XFILLER_30_619 VGND VGND VPWR VPWR sky130_fd_sc_hd__decap_3
XFILLER_42_468 VGND VGND VPWR VPWR sky130_fd_sc_hd__decap_3
XFILLER_52_66 VGND VGND VPWR VPWR sky130_fd_sc_hd__fill_1
XFILLER_10_321 VGND VGND VPWR VPWR sky130_fd_sc_hd__fill_1
XFILLER_10_343 VGND VGND VPWR VPWR sky130_fd_sc_hd__decap_3
XFILLER_22_192 VGND VGND VPWR VPWR sky130_fd_sc_hd__decap_3
XFILLER_52_88 VGND VGND VPWR VPWR sky130_fd_sc_hd__decap_3
XFILLER_10_365 VGND VGND VPWR VPWR sky130_fd_sc_hd__decap_3
XFILLER_108_253 VGND VGND VPWR VPWR sky130_fd_sc_hd__fill_2
XFILLER_10_398 VGND VGND VPWR VPWR sky130_fd_sc_hd__decap_3
XFILLER_6_358 VGND VGND VPWR VPWR sky130_fd_sc_hd__decap_3
XPHY_EDGE_ROW_70_Left_179 VGND VGND VPWR VPWR sky130_fd_sc_hd__decap_3
XFILLER_2_520 VGND VGND VPWR VPWR sky130_fd_sc_hd__decap_3
XFILLER_2_531 VGND VGND VPWR VPWR sky130_fd_sc_hd__fill_1
XFILLER_2_542 VGND VGND VPWR VPWR sky130_fd_sc_hd__decap_3
XFILLER_2_575 VGND VGND VPWR VPWR sky130_fd_sc_hd__decap_3
XFILLER_96_107 VGND VGND VPWR VPWR sky130_fd_sc_hd__decap_3
XFILLER_77_52 VGND VGND VPWR VPWR sky130_fd_sc_hd__decap_3
XFILLER_96_129 VGND VGND VPWR VPWR sky130_fd_sc_hd__decap_3
XFILLER_77_343 VGND VGND VPWR VPWR sky130_fd_sc_hd__decap_3
XFILLER_92_302 VGND VGND VPWR VPWR sky130_fd_sc_hd__decap_3
XFILLER_18_432 VGND VGND VPWR VPWR sky130_fd_sc_hd__decap_3
XFILLER_80_508 VGND VGND VPWR VPWR sky130_fd_sc_hd__decap_3
XFILLER_92_335 VGND VGND VPWR VPWR sky130_fd_sc_hd__decap_3
XFILLER_92_368 VGND VGND VPWR VPWR sky130_fd_sc_hd__decap_3
XFILLER_33_446 VGND VGND VPWR VPWR sky130_fd_sc_hd__fill_2
XFILLER_45_273 VGND VGND VPWR VPWR sky130_fd_sc_hd__decap_3
XFILLER_45_284 VGND VGND VPWR VPWR sky130_fd_sc_hd__decap_3
XFILLER_60_210 VGND VGND VPWR VPWR sky130_fd_sc_hd__decap_3
XFILLER_21_608 VGND VGND VPWR VPWR sky130_fd_sc_hd__decap_3
XFILLER_33_479 VGND VGND VPWR VPWR sky130_fd_sc_hd__decap_3
XFILLER_60_265 VGND VGND VPWR VPWR sky130_fd_sc_hd__decap_3
XFILLER_20_118 VGND VGND VPWR VPWR sky130_fd_sc_hd__fill_2
XFILLER_20_129 VGND VGND VPWR VPWR sky130_fd_sc_hd__fill_2
XFILLER_60_298 VGND VGND VPWR VPWR sky130_fd_sc_hd__fill_1
X_3720_ _6911_/Q _3881_/A2 _3881_/B1 _6903_/Q VGND VGND VPWR VPWR _3720_/X sky130_fd_sc_hd__a22o_2
XFILLER_41_490 VGND VGND VPWR VPWR sky130_fd_sc_hd__decap_3
Xclkbuf_leaf_40_clk clkload0/A VGND VGND VPWR VPWR _7387_/CLK sky130_fd_sc_hd__clkbuf_16
XFILLER_9_152 VGND VGND VPWR VPWR sky130_fd_sc_hd__decap_3
XFILLER_9_130 VGND VGND VPWR VPWR sky130_fd_sc_hd__decap_3
X_3651_ _3665_/A _3665_/B VGND VGND VPWR VPWR _3651_/Y sky130_fd_sc_hd__nor2_2
XFILLER_61_3 VGND VGND VPWR VPWR sky130_fd_sc_hd__decap_3
X_6370_ _6603_/A VGND VGND VPWR VPWR _6370_/Y sky130_fd_sc_hd__inv_2
X_3582_ _7348_/Q _4288_/B _3407_/X _7124_/Q VGND VGND VPWR VPWR _3583_/C sky130_fd_sc_hd__a22o_2
XTAP_TAPCELL_ROW_11_360 VGND VPWR sky130_fd_sc_hd__tapvpwrvgnd_1
XFILLER_9_196 VGND VGND VPWR VPWR sky130_fd_sc_hd__decap_3
X_5321_ _5321_/A0 _4932_/X _5333_/S VGND VGND VPWR VPWR _7170_/D sky130_fd_sc_hd__mux2_2
XFILLER_102_407 VGND VGND VPWR VPWR sky130_fd_sc_hd__decap_3
X_4203_ _4203_/A _4203_/B _4203_/C VGND VGND VPWR VPWR _4203_/X sky130_fd_sc_hd__and3_2
XFILLER_68_365 VGND VGND VPWR VPWR sky130_fd_sc_hd__decap_3
X_4134_ _7020_/Q _4422_/A2 _3939_/S _7203_/Q _4133_/X VGND VGND VPWR VPWR _4134_/X
+ sky130_fd_sc_hd__a221o_2
XFILLER_28_207 VGND VGND VPWR VPWR sky130_fd_sc_hd__decap_3
XFILLER_83_302 VGND VGND VPWR VPWR sky130_fd_sc_hd__decap_3
XFILLER_95_162 VGND VGND VPWR VPWR sky130_fd_sc_hd__decap_3
XFILLER_95_184 VGND VGND VPWR VPWR sky130_fd_sc_hd__decap_3
XFILLER_83_346 VGND VGND VPWR VPWR sky130_fd_sc_hd__decap_3
X_4065_ _7052_/Q _4488_/S _4437_/B1 _7404_/Q _4064_/X VGND VGND VPWR VPWR _4065_/X
+ sky130_fd_sc_hd__a221o_2
XFILLER_36_262 VGND VGND VPWR VPWR sky130_fd_sc_hd__decap_3
XFILLER_83_379 VGND VGND VPWR VPWR sky130_fd_sc_hd__decap_3
XFILLER_24_424 VGND VGND VPWR VPWR sky130_fd_sc_hd__fill_2
XTAP_TAPCELL_ROW_47_780 VGND VPWR sky130_fd_sc_hd__tapvpwrvgnd_1
XFILLER_12_619 VGND VGND VPWR VPWR sky130_fd_sc_hd__decap_3
XFILLER_24_468 VGND VGND VPWR VPWR sky130_fd_sc_hd__decap_3
XFILLER_11_107 VGND VGND VPWR VPWR sky130_fd_sc_hd__decap_3
XFILLER_11_129 VGND VGND VPWR VPWR sky130_fd_sc_hd__decap_3
XFILLER_51_276 VGND VGND VPWR VPWR sky130_fd_sc_hd__decap_3
XFILLER_51_287 VGND VGND VPWR VPWR sky130_fd_sc_hd__decap_3
X_4967_ _4967_/A _4967_/B VGND VGND VPWR VPWR _4967_/X sky130_fd_sc_hd__or2_2
Xclkbuf_leaf_31_clk clkload0/A VGND VGND VPWR VPWR _7280_/CLK sky130_fd_sc_hd__clkbuf_16
X_6706_ _7071_/CLK _6706_/D VGND VGND VPWR VPWR _6706_/Q sky130_fd_sc_hd__dfxtp_2
X_4898_ _4799_/A _3756_/X _4897_/X _5010_/A VGND VGND VPWR VPWR _4898_/X sky130_fd_sc_hd__a211o_2
X_3918_ _6915_/Q _3926_/A2 _3926_/B1 _6779_/Q _3917_/X VGND VGND VPWR VPWR _3918_/X
+ sky130_fd_sc_hd__a221o_2
X_6637_ _6637_/A VGND VGND VPWR VPWR _6637_/Y sky130_fd_sc_hd__inv_2
X_3849_ _6859_/Q _3853_/A2 _3925_/B1 _6899_/Q _3848_/X VGND VGND VPWR VPWR _3849_/X
+ sky130_fd_sc_hd__a221o_2
X_6568_ _6603_/A VGND VGND VPWR VPWR _6568_/Y sky130_fd_sc_hd__inv_2
XFILLER_3_306 VGND VGND VPWR VPWR sky130_fd_sc_hd__decap_3
XFILLER_98_29 VGND VGND VPWR VPWR sky130_fd_sc_hd__decap_3
XFILLER_105_212 VGND VGND VPWR VPWR sky130_fd_sc_hd__decap_3
XFILLER_105_234 VGND VGND VPWR VPWR sky130_fd_sc_hd__decap_3
X_6499_ _6566_/A VGND VGND VPWR VPWR _6499_/Y sky130_fd_sc_hd__inv_2
XFILLER_105_278 VGND VGND VPWR VPWR sky130_fd_sc_hd__fill_2
Xoutput471 _5656_/B VGND VGND VPWR VPWR alu_result_out[21] sky130_fd_sc_hd__clkdlybuf4s25_1
Xoutput460 _5662_/B VGND VGND VPWR VPWR alu_result_out[11] sky130_fd_sc_hd__clkdlybuf4s25_1
XFILLER_59_321 VGND VGND VPWR VPWR sky130_fd_sc_hd__decap_3
XFILLER_78_129 VGND VGND VPWR VPWR sky130_fd_sc_hd__fill_1
Xoutput493 _3525_/A VGND VGND VPWR VPWR instruction_out[13] sky130_fd_sc_hd__clkdlybuf4s25_1
Xoutput482 _5654_/Y VGND VGND VPWR VPWR alu_result_out[31] sky130_fd_sc_hd__clkdlybuf4s25_1
XFILLER_101_440 VGND VGND VPWR VPWR sky130_fd_sc_hd__decap_3
XFILLER_87_641 VGND VGND VPWR VPWR sky130_fd_sc_hd__decap_3
XFILLER_101_473 VGND VGND VPWR VPWR sky130_fd_sc_hd__decap_3
XFILLER_19_218 VGND VGND VPWR VPWR sky130_fd_sc_hd__fill_2
XFILLER_47_538 VGND VGND VPWR VPWR sky130_fd_sc_hd__fill_1
XFILLER_59_365 VGND VGND VPWR VPWR sky130_fd_sc_hd__fill_2
XFILLER_59_376 VGND VGND VPWR VPWR sky130_fd_sc_hd__fill_2
XFILLER_74_346 VGND VGND VPWR VPWR sky130_fd_sc_hd__decap_3
XFILLER_15_402 VGND VGND VPWR VPWR sky130_fd_sc_hd__decap_3
XFILLER_27_262 VGND VGND VPWR VPWR sky130_fd_sc_hd__decap_3
XFILLER_74_368 VGND VGND VPWR VPWR sky130_fd_sc_hd__fill_2
XFILLER_15_424 VGND VGND VPWR VPWR sky130_fd_sc_hd__decap_3
XFILLER_27_295 VGND VGND VPWR VPWR sky130_fd_sc_hd__decap_3
XFILLER_42_221 VGND VGND VPWR VPWR sky130_fd_sc_hd__decap_3
XFILLER_63_32 VGND VGND VPWR VPWR sky130_fd_sc_hd__decap_3
XFILLER_30_416 VGND VGND VPWR VPWR sky130_fd_sc_hd__decap_3
XFILLER_42_287 VGND VGND VPWR VPWR sky130_fd_sc_hd__fill_2
XFILLER_11_641 VGND VGND VPWR VPWR sky130_fd_sc_hd__decap_3
XFILLER_30_449 VGND VGND VPWR VPWR sky130_fd_sc_hd__decap_3
XFILLER_42_298 VGND VGND VPWR VPWR sky130_fd_sc_hd__decap_3
XFILLER_8_27 VGND VGND VPWR VPWR sky130_fd_sc_hd__fill_1
Xclkbuf_leaf_22_clk clkload2/A VGND VGND VPWR VPWR _7372_/CLK sky130_fd_sc_hd__clkbuf_16
XFILLER_7_612 VGND VGND VPWR VPWR sky130_fd_sc_hd__decap_3
XFILLER_7_623 VGND VGND VPWR VPWR sky130_fd_sc_hd__decap_3
XTAP_TAPCELL_ROW_77_1118 VGND VPWR sky130_fd_sc_hd__tapvpwrvgnd_1
XFILLER_6_166 VGND VGND VPWR VPWR sky130_fd_sc_hd__decap_3
XFILLER_97_405 VGND VGND VPWR VPWR sky130_fd_sc_hd__decap_3
XFILLER_2_361 VGND VGND VPWR VPWR sky130_fd_sc_hd__decap_3
XFILLER_97_449 VGND VGND VPWR VPWR sky130_fd_sc_hd__decap_3
XFILLER_77_140 VGND VGND VPWR VPWR sky130_fd_sc_hd__decap_3
XFILLER_78_641 VGND VGND VPWR VPWR sky130_fd_sc_hd__decap_3
XFILLER_65_313 VGND VGND VPWR VPWR sky130_fd_sc_hd__fill_2
XPHY_EDGE_ROW_108_Left_217 VGND VGND VPWR VPWR sky130_fd_sc_hd__decap_3
XFILLER_65_335 VGND VGND VPWR VPWR sky130_fd_sc_hd__fill_1
XFILLER_77_184 VGND VGND VPWR VPWR sky130_fd_sc_hd__decap_3
XFILLER_93_644 VGND VGND VPWR VPWR sky130_fd_sc_hd__decap_3
XTAP_TAPCELL_ROW_88_1247 VGND VPWR sky130_fd_sc_hd__tapvpwrvgnd_1
XFILLER_18_240 VGND VGND VPWR VPWR sky130_fd_sc_hd__decap_3
XFILLER_65_379 VGND VGND VPWR VPWR sky130_fd_sc_hd__fill_1
XFILLER_92_165 VGND VGND VPWR VPWR sky130_fd_sc_hd__decap_3
XFILLER_18_284 VGND VGND VPWR VPWR sky130_fd_sc_hd__decap_3
XFILLER_33_210 VGND VGND VPWR VPWR sky130_fd_sc_hd__decap_3
XFILLER_80_327 VGND VGND VPWR VPWR sky130_fd_sc_hd__decap_3
XFILLER_80_349 VGND VGND VPWR VPWR sky130_fd_sc_hd__decap_3
X_4821_ _4799_/A _3704_/X _4819_/X _5010_/A VGND VGND VPWR VPWR _4821_/X sky130_fd_sc_hd__a211o_2
XFILLER_33_276 VGND VGND VPWR VPWR sky130_fd_sc_hd__decap_3
XFILLER_61_596 VGND VGND VPWR VPWR sky130_fd_sc_hd__decap_3
XFILLER_21_449 VGND VGND VPWR VPWR sky130_fd_sc_hd__decap_3
Xclkbuf_leaf_13_clk clkload1/A VGND VGND VPWR VPWR _6966_/CLK sky130_fd_sc_hd__clkbuf_16
X_4752_ _4878_/A1 _7006_/D _4751_/Y VGND VGND VPWR VPWR _4752_/X sky130_fd_sc_hd__a21o_2
X_4683_ _6997_/Q _6998_/Q _5628_/B VGND VGND VPWR VPWR _4683_/X sky130_fd_sc_hd__o21a_2
X_3703_ _6938_/Q _3884_/A2 _3824_/B1 _6802_/Q VGND VGND VPWR VPWR _3703_/X sky130_fd_sc_hd__a22o_2
X_6422_ _6645_/A VGND VGND VPWR VPWR _6422_/Y sky130_fd_sc_hd__inv_2
X_3634_ _3636_/B _3631_/Y _3632_/X _3633_/Y VGND VGND VPWR VPWR _3634_/Y sky130_fd_sc_hd__o211ai_4
XTAP_TAPCELL_ROW_99_1376 VGND VPWR sky130_fd_sc_hd__tapvpwrvgnd_1
X_6353_ _6684_/A VGND VGND VPWR VPWR _6353_/Y sky130_fd_sc_hd__inv_2
X_3565_ _3469_/A _3469_/B _3564_/X _3449_/A VGND VGND VPWR VPWR _5648_/B sky130_fd_sc_hd__o211a_2
X_6284_ _6397_/A VGND VGND VPWR VPWR _6284_/Y sky130_fd_sc_hd__inv_2
X_5304_ _5304_/A0 _4792_/X _5310_/S VGND VGND VPWR VPWR _7178_/D sky130_fd_sc_hd__mux2_2
X_3496_ _7215_/Q _4353_/A2 _5063_/S _7279_/Q _3495_/X VGND VGND VPWR VPWR _3496_/X
+ sky130_fd_sc_hd__a221o_2
XFILLER_102_226 VGND VGND VPWR VPWR sky130_fd_sc_hd__decap_3
XFILLER_102_248 VGND VGND VPWR VPWR sky130_fd_sc_hd__decap_3
XFILLER_102_259 VGND VGND VPWR VPWR sky130_fd_sc_hd__fill_1
XFILLER_69_641 VGND VGND VPWR VPWR sky130_fd_sc_hd__decap_3
XFILLER_29_505 VGND VGND VPWR VPWR sky130_fd_sc_hd__decap_3
XFILLER_56_302 VGND VGND VPWR VPWR sky130_fd_sc_hd__fill_1
XFILLER_68_162 VGND VGND VPWR VPWR sky130_fd_sc_hd__decap_3
X_5097_ _6985_/Q _5120_/A VGND VGND VPWR VPWR _5098_/B sky130_fd_sc_hd__nor2_2
X_4117_ _4205_/A _4117_/B _4117_/C VGND VGND VPWR VPWR _4117_/Y sky130_fd_sc_hd__nand3_2
XFILLER_56_368 VGND VGND VPWR VPWR sky130_fd_sc_hd__decap_3
XFILLER_71_305 VGND VGND VPWR VPWR sky130_fd_sc_hd__decap_3
XFILLER_83_143 VGND VGND VPWR VPWR sky130_fd_sc_hd__decap_3
XFILLER_83_165 VGND VGND VPWR VPWR sky130_fd_sc_hd__decap_3
X_4048_ _7117_/Q _4434_/A2 _4434_/B1 _7149_/Q VGND VGND VPWR VPWR _4048_/X sky130_fd_sc_hd__a22o_2
XFILLER_17_69 VGND VGND VPWR VPWR sky130_fd_sc_hd__decap_3
XFILLER_83_187 VGND VGND VPWR VPWR sky130_fd_sc_hd__decap_3
XTAP_TAPCELL_ROW_108_1483 VGND VPWR sky130_fd_sc_hd__tapvpwrvgnd_1
XTAP_TAPCELL_ROW_108_1472 VGND VPWR sky130_fd_sc_hd__tapvpwrvgnd_1
XFILLER_24_221 VGND VGND VPWR VPWR sky130_fd_sc_hd__decap_3
XFILLER_52_563 VGND VGND VPWR VPWR sky130_fd_sc_hd__fill_1
XFILLER_12_405 VGND VGND VPWR VPWR sky130_fd_sc_hd__decap_3
XFILLER_33_24 VGND VGND VPWR VPWR sky130_fd_sc_hd__decap_3
XFILLER_12_438 VGND VGND VPWR VPWR sky130_fd_sc_hd__decap_3
XFILLER_24_298 VGND VGND VPWR VPWR sky130_fd_sc_hd__decap_3
XFILLER_33_57 VGND VGND VPWR VPWR sky130_fd_sc_hd__decap_3
XFILLER_8_409 VGND VGND VPWR VPWR sky130_fd_sc_hd__decap_3
XTAP_TAPCELL_ROW_22_488 VGND VPWR sky130_fd_sc_hd__tapvpwrvgnd_1
XFILLER_4_604 VGND VGND VPWR VPWR sky130_fd_sc_hd__decap_3
XFILLER_106_521 VGND VGND VPWR VPWR sky130_fd_sc_hd__decap_3
XFILLER_4_637 VGND VGND VPWR VPWR sky130_fd_sc_hd__decap_3
XFILLER_3_158 VGND VGND VPWR VPWR sky130_fd_sc_hd__decap_3
XFILLER_3_169 VGND VGND VPWR VPWR sky130_fd_sc_hd__decap_3
XFILLER_106_587 VGND VGND VPWR VPWR sky130_fd_sc_hd__fill_1
XFILLER_106_598 VGND VGND VPWR VPWR sky130_fd_sc_hd__decap_3
XFILLER_79_449 VGND VGND VPWR VPWR sky130_fd_sc_hd__decap_3
XTAP_TAPCELL_ROW_72_1059 VGND VPWR sky130_fd_sc_hd__tapvpwrvgnd_1
XFILLER_58_65 VGND VGND VPWR VPWR sky130_fd_sc_hd__decap_3
XFILLER_94_408 VGND VGND VPWR VPWR sky130_fd_sc_hd__decap_3
XFILLER_101_281 VGND VGND VPWR VPWR sky130_fd_sc_hd__decap_3
XFILLER_75_644 VGND VGND VPWR VPWR sky130_fd_sc_hd__decap_3
XFILLER_74_165 VGND VGND VPWR VPWR sky130_fd_sc_hd__decap_3
XFILLER_62_338 VGND VGND VPWR VPWR sky130_fd_sc_hd__decap_3
XFILLER_74_75 VGND VGND VPWR VPWR sky130_fd_sc_hd__fill_1
XFILLER_90_636 VGND VGND VPWR VPWR sky130_fd_sc_hd__decap_3
XTAP_TAPCELL_ROW_58_897 VGND VPWR sky130_fd_sc_hd__tapvpwrvgnd_1
XFILLER_55_390 VGND VGND VPWR VPWR sky130_fd_sc_hd__fill_2
XFILLER_15_254 VGND VGND VPWR VPWR sky130_fd_sc_hd__decap_3
XFILLER_70_371 VGND VGND VPWR VPWR sky130_fd_sc_hd__decap_3
XTAP_TAPCELL_ROW_83_1188 VGND VPWR sky130_fd_sc_hd__tapvpwrvgnd_1
XFILLER_30_224 VGND VGND VPWR VPWR sky130_fd_sc_hd__decap_3
XFILLER_11_493 VGND VGND VPWR VPWR sky130_fd_sc_hd__decap_3
X_3350_ _5129_/B _3350_/B VGND VGND VPWR VPWR _3350_/Y sky130_fd_sc_hd__nor2_2
XFILLER_2_180 VGND VGND VPWR VPWR sky130_fd_sc_hd__decap_3
X_5020_ _5020_/A _5020_/B _4373_/Y VGND VGND VPWR VPWR _5020_/X sky130_fd_sc_hd__or3b_2
XFILLER_97_257 VGND VGND VPWR VPWR sky130_fd_sc_hd__fill_2
XFILLER_66_622 VGND VGND VPWR VPWR sky130_fd_sc_hd__decap_3
Xclkbuf_leaf_2_clk clkbuf_leaf_2_clk/A VGND VGND VPWR VPWR clkload4/A sky130_fd_sc_hd__clkbuf_16
Xhold1109 _7328_/Q VGND VGND VPWR VPWR _4503_/A0 sky130_fd_sc_hd__dlygate4sd3_1
XFILLER_93_441 VGND VGND VPWR VPWR sky130_fd_sc_hd__decap_3
XFILLER_65_165 VGND VGND VPWR VPWR sky130_fd_sc_hd__decap_3
XFILLER_65_187 VGND VGND VPWR VPWR sky130_fd_sc_hd__decap_3
XFILLER_80_102 VGND VGND VPWR VPWR sky130_fd_sc_hd__fill_2
XFILLER_80_124 VGND VGND VPWR VPWR sky130_fd_sc_hd__decap_3
XFILLER_81_647 VGND VGND VPWR VPWR sky130_fd_sc_hd__fill_1
X_6971_ _6976_/CLK _6971_/D VGND VGND VPWR VPWR _6971_/Q sky130_fd_sc_hd__dfxtp_2
XFILLER_80_157 VGND VGND VPWR VPWR sky130_fd_sc_hd__decap_3
XFILLER_21_213 VGND VGND VPWR VPWR sky130_fd_sc_hd__decap_3
XFILLER_61_382 VGND VGND VPWR VPWR sky130_fd_sc_hd__decap_3
XFILLER_61_393 VGND VGND VPWR VPWR sky130_fd_sc_hd__decap_3
X_4804_ _4804_/A _4804_/B VGND VGND VPWR VPWR _4804_/X sky130_fd_sc_hd__or2_2
XFILLER_21_268 VGND VGND VPWR VPWR sky130_fd_sc_hd__decap_3
X_4735_ _4735_/A0 _4734_/X _4865_/S VGND VGND VPWR VPWR _7277_/D sky130_fd_sc_hd__mux2_2
XFILLER_9_92 VGND VGND VPWR VPWR sky130_fd_sc_hd__decap_3
X_4666_ _6997_/Q _4667_/B VGND VGND VPWR VPWR _4908_/A sky130_fd_sc_hd__xnor2_2
X_7385_ _7387_/CLK _7385_/D _6665_/Y VGND VGND VPWR VPWR _7385_/Q sky130_fd_sc_hd__dfrtp_2
Xhold910 _6692_/Q VGND VGND VPWR VPWR hold910/X sky130_fd_sc_hd__dlygate4sd3_1
Xhold921 _6711_/Q VGND VGND VPWR VPWR hold921/X sky130_fd_sc_hd__dlygate4sd3_1
X_6405_ _6628_/A VGND VGND VPWR VPWR _6405_/Y sky130_fd_sc_hd__inv_2
X_4597_ _7282_/Q _7250_/Q _4599_/S VGND VGND VPWR VPWR _7282_/D sky130_fd_sc_hd__mux2_2
X_3617_ _4614_/C _3616_/B _5146_/B1 VGND VGND VPWR VPWR _3617_/X sky130_fd_sc_hd__o21a_2
Xhold932 _7016_/Q VGND VGND VPWR VPWR _5624_/A sky130_fd_sc_hd__dlygate4sd3_1
Xhold954 _7189_/Q VGND VGND VPWR VPWR hold954/X sky130_fd_sc_hd__dlygate4sd3_1
Xhold943 _7381_/Q VGND VGND VPWR VPWR hold943/X sky130_fd_sc_hd__dlygate4sd3_1
X_6336_ _6463_/A VGND VGND VPWR VPWR _6336_/Y sky130_fd_sc_hd__inv_2
X_3548_ _3621_/A _4938_/A _5114_/A VGND VGND VPWR VPWR _3548_/X sky130_fd_sc_hd__or3_2
XFILLER_103_502 VGND VGND VPWR VPWR sky130_fd_sc_hd__fill_2
XFILLER_1_629 VGND VGND VPWR VPWR sky130_fd_sc_hd__decap_3
Xhold998 _7262_/Q VGND VGND VPWR VPWR hold998/X sky130_fd_sc_hd__dlygate4sd3_1
Xhold987 _7038_/Q VGND VGND VPWR VPWR hold987/X sky130_fd_sc_hd__dlygate4sd3_1
Xhold976 _7380_/Q VGND VGND VPWR VPWR hold976/X sky130_fd_sc_hd__dlygate4sd3_1
Xhold965 _7320_/Q VGND VGND VPWR VPWR hold965/X sky130_fd_sc_hd__dlygate4sd3_1
XFILLER_103_557 VGND VGND VPWR VPWR sky130_fd_sc_hd__decap_3
X_6267_ _6677_/A VGND VGND VPWR VPWR _6267_/Y sky130_fd_sc_hd__inv_2
X_3479_ _7152_/Q _3409_/X _3478_/X VGND VGND VPWR VPWR _3482_/A sky130_fd_sc_hd__a21o_2
XFILLER_28_46 VGND VGND VPWR VPWR sky130_fd_sc_hd__decap_3
XFILLER_28_57 VGND VGND VPWR VPWR sky130_fd_sc_hd__decap_3
XFILLER_29_335 VGND VGND VPWR VPWR sky130_fd_sc_hd__fill_1
XFILLER_57_644 VGND VGND VPWR VPWR sky130_fd_sc_hd__decap_3
XFILLER_84_430 VGND VGND VPWR VPWR sky130_fd_sc_hd__fill_1
X_5149_ _5145_/A _4852_/A _5147_/X _5148_/X VGND VGND VPWR VPWR _5149_/Y sky130_fd_sc_hd__o211ai_2
XFILLER_17_508 VGND VGND VPWR VPWR sky130_fd_sc_hd__decap_3
XFILLER_56_132 VGND VGND VPWR VPWR sky130_fd_sc_hd__decap_3
XFILLER_84_452 VGND VGND VPWR VPWR sky130_fd_sc_hd__decap_3
XFILLER_56_187 VGND VGND VPWR VPWR sky130_fd_sc_hd__decap_3
XFILLER_71_113 VGND VGND VPWR VPWR sky130_fd_sc_hd__fill_1
XFILLER_71_124 VGND VGND VPWR VPWR sky130_fd_sc_hd__fill_1
XFILLER_72_636 VGND VGND VPWR VPWR sky130_fd_sc_hd__decap_3
XFILLER_37_390 VGND VGND VPWR VPWR sky130_fd_sc_hd__fill_2
XFILLER_71_146 VGND VGND VPWR VPWR sky130_fd_sc_hd__decap_3
XTAP_TAPCELL_ROW_55_867 VGND VPWR sky130_fd_sc_hd__tapvpwrvgnd_1
XTAP_TAPCELL_ROW_27_547 VGND VPWR sky130_fd_sc_hd__tapvpwrvgnd_1
XFILLER_25_574 VGND VGND VPWR VPWR sky130_fd_sc_hd__decap_3
XFILLER_40_500 VGND VGND VPWR VPWR sky130_fd_sc_hd__decap_3
XFILLER_44_67 VGND VGND VPWR VPWR sky130_fd_sc_hd__fill_1
XFILLER_52_371 VGND VGND VPWR VPWR sky130_fd_sc_hd__decap_3
XFILLER_12_224 VGND VGND VPWR VPWR sky130_fd_sc_hd__decap_3
XFILLER_40_533 VGND VGND VPWR VPWR sky130_fd_sc_hd__decap_3
XFILLER_40_566 VGND VGND VPWR VPWR sky130_fd_sc_hd__decap_3
XFILLER_8_206 VGND VGND VPWR VPWR sky130_fd_sc_hd__fill_1
XFILLER_8_239 VGND VGND VPWR VPWR sky130_fd_sc_hd__decap_3
XFILLER_60_88 VGND VGND VPWR VPWR sky130_fd_sc_hd__fill_2
XFILLER_4_445 VGND VGND VPWR VPWR sky130_fd_sc_hd__fill_2
XFILLER_69_20 VGND VGND VPWR VPWR sky130_fd_sc_hd__fill_2
XFILLER_79_202 VGND VGND VPWR VPWR sky130_fd_sc_hd__decap_3
XFILLER_67_408 VGND VGND VPWR VPWR sky130_fd_sc_hd__decap_3
XFILLER_79_268 VGND VGND VPWR VPWR sky130_fd_sc_hd__fill_1
XFILLER_48_622 VGND VGND VPWR VPWR sky130_fd_sc_hd__decap_3
XFILLER_85_52 VGND VGND VPWR VPWR sky130_fd_sc_hd__decap_3
XFILLER_94_238 VGND VGND VPWR VPWR sky130_fd_sc_hd__decap_3
XFILLER_47_143 VGND VGND VPWR VPWR sky130_fd_sc_hd__decap_3
XFILLER_75_452 VGND VGND VPWR VPWR sky130_fd_sc_hd__decap_3
XFILLER_62_113 VGND VGND VPWR VPWR sky130_fd_sc_hd__decap_3
XFILLER_63_647 VGND VGND VPWR VPWR sky130_fd_sc_hd__fill_1
XFILLER_90_411 VGND VGND VPWR VPWR sky130_fd_sc_hd__decap_3
XTAP_TAPCELL_ROW_85_1217 VGND VPWR sky130_fd_sc_hd__tapvpwrvgnd_1
XFILLER_62_135 VGND VGND VPWR VPWR sky130_fd_sc_hd__decap_3
XFILLER_62_157 VGND VGND VPWR VPWR sky130_fd_sc_hd__fill_2
XFILLER_16_574 VGND VGND VPWR VPWR sky130_fd_sc_hd__decap_3
XFILLER_90_477 VGND VGND VPWR VPWR sky130_fd_sc_hd__decap_3
XFILLER_11_290 VGND VGND VPWR VPWR sky130_fd_sc_hd__decap_3
X_4520_ _4520_/A0 _7287_/Q _4520_/S VGND VGND VPWR VPWR _7319_/D sky130_fd_sc_hd__mux2_2
XTAP_TAPCELL_ROW_96_1335 VGND VPWR sky130_fd_sc_hd__tapvpwrvgnd_1
XFILLER_7_261 VGND VGND VPWR VPWR sky130_fd_sc_hd__decap_3
X_4451_ _4451_/A _4451_/B VGND VGND VPWR VPWR _4765_/B sky130_fd_sc_hd__nor2_2
XFILLER_7_294 VGND VGND VPWR VPWR sky130_fd_sc_hd__decap_3
X_7170_ _7361_/CLK _7170_/D _6450_/Y VGND VGND VPWR VPWR _7170_/Q sky130_fd_sc_hd__dfrtp_2
X_3402_ _3385_/Y _3401_/X _4307_/A2 VGND VGND VPWR VPWR _3421_/C sky130_fd_sc_hd__a21oi_4
X_4382_ _4950_/A _4967_/B VGND VGND VPWR VPWR _4383_/C sky130_fd_sc_hd__nor2_2
XFILLER_98_533 VGND VGND VPWR VPWR sky130_fd_sc_hd__decap_3
XFILLER_98_500 VGND VGND VPWR VPWR sky130_fd_sc_hd__decap_3
XFILLER_98_566 VGND VGND VPWR VPWR sky130_fd_sc_hd__fill_2
XFILLER_105_29 VGND VGND VPWR VPWR sky130_fd_sc_hd__decap_3
XPHY_EDGE_ROW_7_Right_7 VGND VGND VPWR VPWR sky130_fd_sc_hd__decap_3
XFILLER_39_644 VGND VGND VPWR VPWR sky130_fd_sc_hd__decap_3
X_5003_ _5003_/A _5003_/B VGND VGND VPWR VPWR _5003_/X sky130_fd_sc_hd__or2_2
XFILLER_66_441 VGND VGND VPWR VPWR sky130_fd_sc_hd__decap_3
XFILLER_26_338 VGND VGND VPWR VPWR sky130_fd_sc_hd__fill_1
XFILLER_53_113 VGND VGND VPWR VPWR sky130_fd_sc_hd__fill_1
XFILLER_54_614 VGND VGND VPWR VPWR sky130_fd_sc_hd__decap_3
XFILLER_81_400 VGND VGND VPWR VPWR sky130_fd_sc_hd__decap_3
XFILLER_93_271 VGND VGND VPWR VPWR sky130_fd_sc_hd__decap_3
XFILLER_81_433 VGND VGND VPWR VPWR sky130_fd_sc_hd__fill_2
XFILLER_81_444 VGND VGND VPWR VPWR sky130_fd_sc_hd__decap_3
X_6954_ _6966_/CLK _6954_/D VGND VGND VPWR VPWR _6954_/Q sky130_fd_sc_hd__dfxtp_2
XFILLER_81_488 VGND VGND VPWR VPWR sky130_fd_sc_hd__decap_3
XTAP_TAPCELL_ROW_24_506 VGND VPWR sky130_fd_sc_hd__tapvpwrvgnd_1
XTAP_TAPCELL_ROW_105_1442 VGND VPWR sky130_fd_sc_hd__tapvpwrvgnd_1
XFILLER_34_371 VGND VGND VPWR VPWR sky130_fd_sc_hd__decap_3
X_6885_ _6943_/CLK _6885_/D VGND VGND VPWR VPWR _6885_/Q sky130_fd_sc_hd__dfxtp_2
XTAP_TAPCELL_ROW_52_837 VGND VPWR sky130_fd_sc_hd__tapvpwrvgnd_1
XFILLER_108_605 VGND VGND VPWR VPWR sky130_fd_sc_hd__decap_3
X_4718_ _4718_/A0 _4716_/X _4865_/S VGND VGND VPWR VPWR _7278_/D sky130_fd_sc_hd__mux2_4
XFILLER_30_36 VGND VGND VPWR VPWR sky130_fd_sc_hd__fill_1
X_4649_ _4649_/A _4649_/B _4425_/C VGND VGND VPWR VPWR _4652_/A sky130_fd_sc_hd__nor3b_2
X_7368_ _7374_/CLK _7368_/D _6648_/Y VGND VGND VPWR VPWR _7368_/Q sky130_fd_sc_hd__dfrtp_2
Xhold740 _6898_/Q VGND VGND VPWR VPWR _6898_/D sky130_fd_sc_hd__dlygate4sd3_1
Xhold751 _6956_/Q VGND VGND VPWR VPWR _6956_/D sky130_fd_sc_hd__dlygate4sd3_1
Xhold762 _6826_/Q VGND VGND VPWR VPWR _6826_/D sky130_fd_sc_hd__dlygate4sd3_1
Xhold773 _6776_/Q VGND VGND VPWR VPWR _6776_/D sky130_fd_sc_hd__dlygate4sd3_1
XFILLER_103_332 VGND VGND VPWR VPWR sky130_fd_sc_hd__decap_3
XFILLER_103_343 VGND VGND VPWR VPWR sky130_fd_sc_hd__decap_3
X_7299_ _7374_/CLK _7299_/D _6579_/Y VGND VGND VPWR VPWR _7299_/Q sky130_fd_sc_hd__dfrtp_2
Xhold784 _6927_/Q VGND VGND VPWR VPWR _6927_/D sky130_fd_sc_hd__dlygate4sd3_1
Xhold795 _6818_/Q VGND VGND VPWR VPWR _6818_/D sky130_fd_sc_hd__dlygate4sd3_1
X_6319_ _6668_/A VGND VGND VPWR VPWR _6319_/Y sky130_fd_sc_hd__inv_2
XFILLER_103_376 VGND VGND VPWR VPWR sky130_fd_sc_hd__decap_3
XFILLER_76_238 VGND VGND VPWR VPWR sky130_fd_sc_hd__decap_3
XFILLER_29_154 VGND VGND VPWR VPWR sky130_fd_sc_hd__fill_1
XTAP_TAPCELL_ROW_4_275 VGND VPWR sky130_fd_sc_hd__tapvpwrvgnd_1
XFILLER_17_327 VGND VGND VPWR VPWR sky130_fd_sc_hd__fill_2
XFILLER_29_187 VGND VGND VPWR VPWR sky130_fd_sc_hd__decap_3
XTAP_TAPCELL_ROW_4_286 VGND VPWR sky130_fd_sc_hd__tapvpwrvgnd_1
XFILLER_44_135 VGND VGND VPWR VPWR sky130_fd_sc_hd__decap_3
XFILLER_45_647 VGND VGND VPWR VPWR sky130_fd_sc_hd__fill_1
XFILLER_44_168 VGND VGND VPWR VPWR sky130_fd_sc_hd__decap_3
XFILLER_60_606 VGND VGND VPWR VPWR sky130_fd_sc_hd__decap_3
XFILLER_60_639 VGND VGND VPWR VPWR sky130_fd_sc_hd__decap_3
XFILLER_72_477 VGND VGND VPWR VPWR sky130_fd_sc_hd__decap_3
XFILLER_72_488 VGND VGND VPWR VPWR sky130_fd_sc_hd__decap_3
XFILLER_13_544 VGND VGND VPWR VPWR sky130_fd_sc_hd__decap_3
XFILLER_25_371 VGND VGND VPWR VPWR sky130_fd_sc_hd__decap_3
XFILLER_25_382 VGND VGND VPWR VPWR sky130_fd_sc_hd__decap_3
XFILLER_40_352 VGND VGND VPWR VPWR sky130_fd_sc_hd__fill_2
XTAP_TAPCELL_ROW_80_1158 VGND VPWR sky130_fd_sc_hd__tapvpwrvgnd_1
XFILLER_13_588 VGND VGND VPWR VPWR sky130_fd_sc_hd__decap_3
XFILLER_9_559 VGND VGND VPWR VPWR sky130_fd_sc_hd__fill_1
XFILLER_4_220 VGND VGND VPWR VPWR sky130_fd_sc_hd__decap_3
XFILLER_4_253 VGND VGND VPWR VPWR sky130_fd_sc_hd__decap_3
XFILLER_4_275 VGND VGND VPWR VPWR sky130_fd_sc_hd__decap_3
XFILLER_20_91 VGND VGND VPWR VPWR sky130_fd_sc_hd__decap_3
XFILLER_4_297 VGND VGND VPWR VPWR sky130_fd_sc_hd__decap_3
XTAP_TAPCELL_ROW_91_1276 VGND VPWR sky130_fd_sc_hd__tapvpwrvgnd_1
XFILLER_48_430 VGND VGND VPWR VPWR sky130_fd_sc_hd__decap_3
XFILLER_36_614 VGND VGND VPWR VPWR sky130_fd_sc_hd__decap_3
XFILLER_82_219 VGND VGND VPWR VPWR sky130_fd_sc_hd__fill_1
XFILLER_63_433 VGND VGND VPWR VPWR sky130_fd_sc_hd__decap_3
Xplace400 _3488_/B VGND VGND VPWR VPWR _4534_/S sky130_fd_sc_hd__buf_2
Xplace411 _4399_/A2 VGND VGND VPWR VPWR _4419_/B1 sky130_fd_sc_hd__buf_2
Xplace422 _3958_/S VGND VGND VPWR VPWR _3975_/S sky130_fd_sc_hd__buf_2
XFILLER_35_157 VGND VGND VPWR VPWR sky130_fd_sc_hd__fill_1
XFILLER_35_179 VGND VGND VPWR VPWR sky130_fd_sc_hd__decap_3
XFILLER_51_617 VGND VGND VPWR VPWR sky130_fd_sc_hd__decap_3
Xplace433 _5156_/S VGND VGND VPWR VPWR _5061_/S sky130_fd_sc_hd__buf_2
Xplace444 _3332_/B VGND VGND VPWR VPWR _4307_/A2 sky130_fd_sc_hd__buf_2
Xplace455 _6979_/Q VGND VGND VPWR VPWR _5667_/A sky130_fd_sc_hd__buf_2
XFILLER_16_371 VGND VGND VPWR VPWR sky130_fd_sc_hd__decap_3
XFILLER_50_127 VGND VGND VPWR VPWR sky130_fd_sc_hd__decap_3
X_6670_ _6678_/A VGND VGND VPWR VPWR _6670_/Y sky130_fd_sc_hd__inv_2
X_3882_ _6974_/Q _3883_/A2 _3913_/B1 _6969_/Q _3881_/X VGND VGND VPWR VPWR _3882_/X
+ sky130_fd_sc_hd__a221o_2
XFILLER_31_396 VGND VGND VPWR VPWR sky130_fd_sc_hd__decap_3
X_5621_ _5621_/A VGND VGND VPWR VPWR _5622_/A sky130_fd_sc_hd__inv_2
XTAP_TAPCELL_ROW_100_1383 VGND VPWR sky130_fd_sc_hd__tapvpwrvgnd_1
XFILLER_8_581 VGND VGND VPWR VPWR sky130_fd_sc_hd__decap_3
XFILLER_8_592 VGND VGND VPWR VPWR sky130_fd_sc_hd__decap_3
X_4503_ _4503_/A0 _7296_/Q _4520_/S VGND VGND VPWR VPWR _7328_/D sky130_fd_sc_hd__mux2_2
X_7222_ _7348_/CLK _7222_/D _6502_/Y VGND VGND VPWR VPWR _7222_/Q sky130_fd_sc_hd__dfrtp_2
X_4434_ _7111_/Q _4434_/A2 _4434_/B1 _7143_/Q _4433_/X VGND VGND VPWR VPWR _4434_/X
+ sky130_fd_sc_hd__a221o_2
X_7153_ _7376_/CLK _7153_/D _6433_/Y VGND VGND VPWR VPWR _7153_/Q sky130_fd_sc_hd__dfrtp_2
X_4365_ _4365_/A _4365_/B _4365_/C VGND VGND VPWR VPWR _4365_/X sky130_fd_sc_hd__and3_2
XFILLER_98_341 VGND VGND VPWR VPWR sky130_fd_sc_hd__decap_3
XFILLER_98_330 VGND VGND VPWR VPWR sky130_fd_sc_hd__decap_3
X_7084_ _7405_/CLK _7084_/D _6364_/Y VGND VGND VPWR VPWR _7084_/Q sky130_fd_sc_hd__dfrtp_2
X_3316_ _3365_/A _5670_/A VGND VGND VPWR VPWR _3332_/B sky130_fd_sc_hd__nor2b_2
XFILLER_100_324 VGND VGND VPWR VPWR sky130_fd_sc_hd__fill_2
XFILLER_58_227 VGND VGND VPWR VPWR sky130_fd_sc_hd__decap_3
X_4296_ _4292_/A _3591_/Y _4295_/X VGND VGND VPWR VPWR _4297_/B sky130_fd_sc_hd__a21oi_2
XFILLER_100_346 VGND VGND VPWR VPWR sky130_fd_sc_hd__decap_3
XFILLER_100_368 VGND VGND VPWR VPWR sky130_fd_sc_hd__decap_3
XFILLER_26_102 VGND VGND VPWR VPWR sky130_fd_sc_hd__decap_3
XFILLER_27_603 VGND VGND VPWR VPWR sky130_fd_sc_hd__decap_3
XFILLER_39_463 VGND VGND VPWR VPWR sky130_fd_sc_hd__decap_3
XFILLER_73_219 VGND VGND VPWR VPWR sky130_fd_sc_hd__decap_3
XFILLER_27_647 VGND VGND VPWR VPWR sky130_fd_sc_hd__fill_1
XFILLER_54_433 VGND VGND VPWR VPWR sky130_fd_sc_hd__fill_2
XFILLER_66_293 VGND VGND VPWR VPWR sky130_fd_sc_hd__fill_1
XTAP_TAPCELL_ROW_1_245 VGND VPWR sky130_fd_sc_hd__tapvpwrvgnd_1
XTAP_TAPCELL_ROW_65_984 VGND VPWR sky130_fd_sc_hd__tapvpwrvgnd_1
XTAP_TAPCELL_ROW_37_664 VGND VPWR sky130_fd_sc_hd__tapvpwrvgnd_1
XFILLER_41_116 VGND VGND VPWR VPWR sky130_fd_sc_hd__decap_3
XFILLER_41_127 VGND VGND VPWR VPWR sky130_fd_sc_hd__fill_1
XFILLER_42_639 VGND VGND VPWR VPWR sky130_fd_sc_hd__decap_3
X_6937_ _7083_/CLK _6937_/D VGND VGND VPWR VPWR _6937_/Q sky130_fd_sc_hd__dfxtp_2
X_6868_ clkload8/A _6868_/D VGND VGND VPWR VPWR _6868_/Q sky130_fd_sc_hd__dfxtp_2
XFILLER_10_503 VGND VGND VPWR VPWR sky130_fd_sc_hd__fill_2
XFILLER_22_363 VGND VGND VPWR VPWR sky130_fd_sc_hd__fill_1
XFILLER_41_46 VGND VGND VPWR VPWR sky130_fd_sc_hd__decap_3
XFILLER_41_57 VGND VGND VPWR VPWR sky130_fd_sc_hd__fill_1
X_6799_ _6965_/CLK _6799_/D VGND VGND VPWR VPWR _6799_/Q sky130_fd_sc_hd__dfxtp_2
XFILLER_108_402 VGND VGND VPWR VPWR sky130_fd_sc_hd__decap_3
XFILLER_108_413 VGND VGND VPWR VPWR sky130_fd_sc_hd__decap_3
XFILLER_108_424 VGND VGND VPWR VPWR sky130_fd_sc_hd__decap_3
XFILLER_108_446 VGND VGND VPWR VPWR sky130_fd_sc_hd__fill_2
XTAP_TAPCELL_ROW_9_334 VGND VPWR sky130_fd_sc_hd__tapvpwrvgnd_1
XFILLER_104_641 VGND VGND VPWR VPWR sky130_fd_sc_hd__decap_3
XFILLER_1_223 VGND VGND VPWR VPWR sky130_fd_sc_hd__fill_1
Xhold581 _6786_/Q VGND VGND VPWR VPWR _6786_/D sky130_fd_sc_hd__dlygate4sd3_1
XFILLER_1_267 VGND VGND VPWR VPWR sky130_fd_sc_hd__fill_1
XFILLER_49_205 VGND VGND VPWR VPWR sky130_fd_sc_hd__decap_3
XFILLER_77_514 VGND VGND VPWR VPWR sky130_fd_sc_hd__decap_3
XFILLER_89_352 VGND VGND VPWR VPWR sky130_fd_sc_hd__decap_3
Xhold592 _6822_/Q VGND VGND VPWR VPWR _6822_/D sky130_fd_sc_hd__dlygate4sd3_1
XFILLER_103_162 VGND VGND VPWR VPWR sky130_fd_sc_hd__decap_3
XFILLER_106_50 VGND VGND VPWR VPWR sky130_fd_sc_hd__decap_3
XFILLER_2_18 VGND VGND VPWR VPWR sky130_fd_sc_hd__fill_1
XFILLER_77_547 VGND VGND VPWR VPWR sky130_fd_sc_hd__decap_3
XFILLER_106_94 VGND VGND VPWR VPWR sky130_fd_sc_hd__decap_3
XFILLER_18_625 VGND VGND VPWR VPWR sky130_fd_sc_hd__decap_3
XFILLER_45_411 VGND VGND VPWR VPWR sky130_fd_sc_hd__decap_3
XFILLER_64_208 VGND VGND VPWR VPWR sky130_fd_sc_hd__decap_3
XFILLER_17_146 VGND VGND VPWR VPWR sky130_fd_sc_hd__decap_3
XFILLER_72_230 VGND VGND VPWR VPWR sky130_fd_sc_hd__decap_3
XFILLER_32_105 VGND VGND VPWR VPWR sky130_fd_sc_hd__decap_3
XFILLER_33_617 VGND VGND VPWR VPWR sky130_fd_sc_hd__decap_3
XFILLER_72_263 VGND VGND VPWR VPWR sky130_fd_sc_hd__fill_2
XFILLER_82_64 VGND VGND VPWR VPWR sky130_fd_sc_hd__decap_3
XFILLER_25_190 VGND VGND VPWR VPWR sky130_fd_sc_hd__decap_3
XFILLER_9_334 VGND VGND VPWR VPWR sky130_fd_sc_hd__fill_2
XFILLER_9_323 VGND VGND VPWR VPWR sky130_fd_sc_hd__decap_3
XFILLER_13_396 VGND VGND VPWR VPWR sky130_fd_sc_hd__fill_2
XFILLER_40_193 VGND VGND VPWR VPWR sky130_fd_sc_hd__decap_3
XFILLER_9_367 VGND VGND VPWR VPWR sky130_fd_sc_hd__fill_1
XFILLER_9_389 VGND VGND VPWR VPWR sky130_fd_sc_hd__decap_3
XTAP_TAPCELL_ROW_93_1305 VGND VPWR sky130_fd_sc_hd__tapvpwrvgnd_1
XFILLER_5_573 VGND VGND VPWR VPWR sky130_fd_sc_hd__decap_3
XFILLER_99_149 VGND VGND VPWR VPWR sky130_fd_sc_hd__decap_3
X_4150_ _7234_/Q _4433_/B _4272_/B _7362_/Q VGND VGND VPWR VPWR _4150_/X sky130_fd_sc_hd__a22o_2
XFILLER_68_536 VGND VGND VPWR VPWR sky130_fd_sc_hd__decap_3
XFILLER_95_322 VGND VGND VPWR VPWR sky130_fd_sc_hd__decap_3
XFILLER_95_333 VGND VGND VPWR VPWR sky130_fd_sc_hd__decap_3
X_4081_ _4451_/A _4451_/B VGND VGND VPWR VPWR _4081_/X sky130_fd_sc_hd__or2b_2
XFILLER_48_271 VGND VGND VPWR VPWR sky130_fd_sc_hd__fill_1
XFILLER_55_208 VGND VGND VPWR VPWR sky130_fd_sc_hd__decap_3
XFILLER_36_433 VGND VGND VPWR VPWR sky130_fd_sc_hd__decap_3
XFILLER_48_282 VGND VGND VPWR VPWR sky130_fd_sc_hd__decap_3
XFILLER_24_628 VGND VGND VPWR VPWR sky130_fd_sc_hd__decap_3
XFILLER_36_455 VGND VGND VPWR VPWR sky130_fd_sc_hd__decap_3
XFILLER_36_477 VGND VGND VPWR VPWR sky130_fd_sc_hd__decap_3
XFILLER_63_263 VGND VGND VPWR VPWR sky130_fd_sc_hd__fill_1
XFILLER_91_550 VGND VGND VPWR VPWR sky130_fd_sc_hd__decap_3
XFILLER_91_561 VGND VGND VPWR VPWR sky130_fd_sc_hd__decap_3
XFILLER_63_274 VGND VGND VPWR VPWR sky130_fd_sc_hd__decap_3
Xplace263 _4926_/Y VGND VGND VPWR VPWR _5656_/C sky130_fd_sc_hd__buf_2
X_4983_ _4983_/A _4983_/B _4983_/C VGND VGND VPWR VPWR _4983_/X sky130_fd_sc_hd__and3_2
XTAP_TAPCELL_ROW_62_943 VGND VPWR sky130_fd_sc_hd__tapvpwrvgnd_1
XTAP_TAPCELL_ROW_34_623 VGND VPWR sky130_fd_sc_hd__tapvpwrvgnd_1
XTAP_TAPCELL_ROW_102_1412 VGND VPWR sky130_fd_sc_hd__tapvpwrvgnd_1
Xplace296 _3853_/A2 VGND VGND VPWR VPWR _3886_/B1 sky130_fd_sc_hd__buf_2
Xplace285 _3893_/B1 VGND VGND VPWR VPWR _3913_/B1 sky130_fd_sc_hd__buf_2
Xplace274 _3665_/X VGND VGND VPWR VPWR _3852_/B1 sky130_fd_sc_hd__buf_2
X_6722_ clkload5/A _6722_/D VGND VGND VPWR VPWR _6722_/Q sky130_fd_sc_hd__dfxtp_2
XFILLER_31_160 VGND VGND VPWR VPWR sky130_fd_sc_hd__decap_3
X_6653_ _6654_/A VGND VGND VPWR VPWR _6653_/Y sky130_fd_sc_hd__inv_2
XTAP_TAPCELL_ROW_14_391 VGND VPWR sky130_fd_sc_hd__tapvpwrvgnd_1
X_6584_ _6618_/A VGND VGND VPWR VPWR _6584_/Y sky130_fd_sc_hd__inv_2
X_3796_ _6726_/Q _3881_/A2 _3879_/B1 _6976_/Q _3795_/X VGND VGND VPWR VPWR _3796_/X
+ sky130_fd_sc_hd__a221o_2
XFILLER_11_27 VGND VGND VPWR VPWR sky130_fd_sc_hd__fill_2
XFILLER_105_405 VGND VGND VPWR VPWR sky130_fd_sc_hd__decap_3
XFILLER_105_449 VGND VGND VPWR VPWR sky130_fd_sc_hd__decap_3
X_7205_ _7269_/CLK _7205_/D _6485_/Y VGND VGND VPWR VPWR _7205_/Q sky130_fd_sc_hd__dfrtp_2
X_4417_ _7304_/Q _4865_/S _4434_/A2 _7112_/Q _4416_/X VGND VGND VPWR VPWR _4417_/X
+ sky130_fd_sc_hd__a221o_2
XTAP_TAPCELL_ROW_6_304 VGND VPWR sky130_fd_sc_hd__tapvpwrvgnd_1
XFILLER_100_110 VGND VGND VPWR VPWR sky130_fd_sc_hd__decap_3
XFILLER_101_611 VGND VGND VPWR VPWR sky130_fd_sc_hd__decap_3
XFILLER_59_547 VGND VGND VPWR VPWR sky130_fd_sc_hd__decap_3
X_7136_ _7362_/CLK _7136_/D _6416_/Y VGND VGND VPWR VPWR _7136_/Q sky130_fd_sc_hd__dfrtp_2
X_4348_ _7161_/Q _4348_/A2 _4348_/B1 _7129_/Q _4347_/X VGND VGND VPWR VPWR _4348_/X
+ sky130_fd_sc_hd__a221o_2
XFILLER_98_182 VGND VGND VPWR VPWR sky130_fd_sc_hd__decap_3
XFILLER_98_171 VGND VGND VPWR VPWR sky130_fd_sc_hd__decap_3
XFILLER_101_644 VGND VGND VPWR VPWR sky130_fd_sc_hd__decap_3
X_7067_ _7387_/CLK _7067_/D _6347_/Y VGND VGND VPWR VPWR _7067_/Q sky130_fd_sc_hd__dfrtp_2
X_4279_ _7318_/Q _3996_/S _4348_/B1 _7126_/Q VGND VGND VPWR VPWR _4279_/X sky130_fd_sc_hd__a22o_2
XFILLER_46_219 VGND VGND VPWR VPWR sky130_fd_sc_hd__decap_3
XFILLER_36_24 VGND VGND VPWR VPWR sky130_fd_sc_hd__decap_3
XTAP_TAPCELL_ROW_68_1020 VGND VPWR sky130_fd_sc_hd__tapvpwrvgnd_1
XFILLER_15_606 VGND VGND VPWR VPWR sky130_fd_sc_hd__decap_3
XFILLER_15_617 VGND VGND VPWR VPWR sky130_fd_sc_hd__decap_3
XFILLER_36_57 VGND VGND VPWR VPWR sky130_fd_sc_hd__decap_3
XFILLER_42_403 VGND VGND VPWR VPWR sky130_fd_sc_hd__decap_3
XFILLER_14_127 VGND VGND VPWR VPWR sky130_fd_sc_hd__decap_3
XFILLER_42_414 VGND VGND VPWR VPWR sky130_fd_sc_hd__fill_1
XFILLER_42_425 VGND VGND VPWR VPWR sky130_fd_sc_hd__decap_3
XFILLER_54_285 VGND VGND VPWR VPWR sky130_fd_sc_hd__decap_3
XFILLER_22_160 VGND VGND VPWR VPWR sky130_fd_sc_hd__decap_3
XFILLER_10_377 VGND VGND VPWR VPWR sky130_fd_sc_hd__decap_3
XFILLER_6_315 VGND VGND VPWR VPWR sky130_fd_sc_hd__decap_3
XFILLER_108_276 VGND VGND VPWR VPWR sky130_fd_sc_hd__decap_3
XFILLER_2_554 VGND VGND VPWR VPWR sky130_fd_sc_hd__decap_3
XFILLER_97_609 VGND VGND VPWR VPWR sky130_fd_sc_hd__decap_3
XFILLER_2_587 VGND VGND VPWR VPWR sky130_fd_sc_hd__fill_1
XFILLER_2_598 VGND VGND VPWR VPWR sky130_fd_sc_hd__decap_3
XFILLER_77_311 VGND VGND VPWR VPWR sky130_fd_sc_hd__fill_1
XFILLER_77_355 VGND VGND VPWR VPWR sky130_fd_sc_hd__fill_1
XFILLER_89_193 VGND VGND VPWR VPWR sky130_fd_sc_hd__decap_3
XFILLER_65_517 VGND VGND VPWR VPWR sky130_fd_sc_hd__decap_3
XFILLER_77_366 VGND VGND VPWR VPWR sky130_fd_sc_hd__fill_1
XFILLER_92_347 VGND VGND VPWR VPWR sky130_fd_sc_hd__decap_3
XFILLER_45_241 VGND VGND VPWR VPWR sky130_fd_sc_hd__decap_3
XFILLER_73_561 VGND VGND VPWR VPWR sky130_fd_sc_hd__decap_3
XFILLER_18_488 VGND VGND VPWR VPWR sky130_fd_sc_hd__decap_3
XFILLER_60_222 VGND VGND VPWR VPWR sky130_fd_sc_hd__decap_3
XFILLER_93_96 VGND VGND VPWR VPWR sky130_fd_sc_hd__decap_3
XFILLER_60_277 VGND VGND VPWR VPWR sky130_fd_sc_hd__decap_3
XFILLER_13_182 VGND VGND VPWR VPWR sky130_fd_sc_hd__decap_3
X_3650_ _3991_/B VGND VGND VPWR VPWR _3665_/A sky130_fd_sc_hd__inv_2
XFILLER_9_175 VGND VGND VPWR VPWR sky130_fd_sc_hd__decap_3
XFILLER_9_164 VGND VGND VPWR VPWR sky130_fd_sc_hd__decap_3
X_3581_ _7156_/Q _3409_/X _3579_/X _3580_/X VGND VGND VPWR VPWR _3583_/B sky130_fd_sc_hd__a211o_2
XTAP_TAPCELL_ROW_11_361 VGND VPWR sky130_fd_sc_hd__tapvpwrvgnd_1
XFILLER_54_3 VGND VGND VPWR VPWR sky130_fd_sc_hd__decap_3
X_5251_ _5251_/A0 _4899_/X _5276_/S VGND VGND VPWR VPWR _7204_/D sky130_fd_sc_hd__mux2_2
XFILLER_102_419 VGND VGND VPWR VPWR sky130_fd_sc_hd__fill_1
X_4202_ _4202_/A VGND VGND VPWR VPWR _4203_/C sky130_fd_sc_hd__inv_2
XFILLER_68_300 VGND VGND VPWR VPWR sky130_fd_sc_hd__decap_3
X_5182_ _5182_/A _5207_/B VGND VGND VPWR VPWR _7237_/D sky130_fd_sc_hd__and2_2
XFILLER_68_355 VGND VGND VPWR VPWR sky130_fd_sc_hd__decap_3
XFILLER_95_130 VGND VGND VPWR VPWR sky130_fd_sc_hd__decap_3
X_4133_ _7363_/Q _4270_/B _4436_/B1 _7171_/Q VGND VGND VPWR VPWR _4133_/X sky130_fd_sc_hd__a22o_2
XFILLER_96_642 VGND VGND VPWR VPWR sky130_fd_sc_hd__fill_2
XFILLER_3_94 VGND VGND VPWR VPWR sky130_fd_sc_hd__fill_1
XFILLER_56_539 VGND VGND VPWR VPWR sky130_fd_sc_hd__decap_3
XFILLER_68_377 VGND VGND VPWR VPWR sky130_fd_sc_hd__decap_3
X_4064_ _7372_/Q _4394_/B _4946_/S _7308_/Q _4063_/X VGND VGND VPWR VPWR _4064_/X
+ sky130_fd_sc_hd__a221o_2
XFILLER_83_358 VGND VGND VPWR VPWR sky130_fd_sc_hd__decap_3
XFILLER_24_403 VGND VGND VPWR VPWR sky130_fd_sc_hd__decap_3
XFILLER_36_241 VGND VGND VPWR VPWR sky130_fd_sc_hd__decap_3
XFILLER_71_509 VGND VGND VPWR VPWR sky130_fd_sc_hd__fill_2
XTAP_TAPCELL_ROW_19_450 VGND VPWR sky130_fd_sc_hd__tapvpwrvgnd_1
XFILLER_51_200 VGND VGND VPWR VPWR sky130_fd_sc_hd__decap_3
XFILLER_64_572 VGND VGND VPWR VPWR sky130_fd_sc_hd__decap_3
XFILLER_91_380 VGND VGND VPWR VPWR sky130_fd_sc_hd__decap_3
XTAP_TAPCELL_ROW_47_770 VGND VPWR sky130_fd_sc_hd__tapvpwrvgnd_1
XFILLER_24_447 VGND VGND VPWR VPWR sky130_fd_sc_hd__decap_3
X_6705_ _7071_/CLK _6705_/D VGND VGND VPWR VPWR _6705_/Q sky130_fd_sc_hd__dfxtp_2
XFILLER_20_631 VGND VGND VPWR VPWR sky130_fd_sc_hd__decap_3
XFILLER_32_480 VGND VGND VPWR VPWR sky130_fd_sc_hd__fill_1
XFILLER_51_299 VGND VGND VPWR VPWR sky130_fd_sc_hd__decap_3
X_4897_ _4896_/A _4896_/B _4896_/Y _4777_/A VGND VGND VPWR VPWR _4897_/X sky130_fd_sc_hd__o211a_2
X_3917_ _6689_/Q _5660_/B _3925_/B1 _6867_/Q VGND VGND VPWR VPWR _3917_/X sky130_fd_sc_hd__a22o_2
XFILLER_22_26 VGND VGND VPWR VPWR sky130_fd_sc_hd__fill_2
X_6636_ _6636_/A VGND VGND VPWR VPWR _6636_/Y sky130_fd_sc_hd__inv_2
X_3848_ _6907_/Q _3926_/A2 _5660_/B _6851_/Q VGND VGND VPWR VPWR _3848_/X sky130_fd_sc_hd__a22o_2
X_6567_ _6603_/A VGND VGND VPWR VPWR _6567_/Y sky130_fd_sc_hd__inv_2
X_3779_ _6794_/Q _3651_/Y _3887_/A2 _6704_/Q _3778_/X VGND VGND VPWR VPWR _3779_/X
+ sky130_fd_sc_hd__a221o_2
X_6498_ _6592_/A VGND VGND VPWR VPWR _6498_/Y sky130_fd_sc_hd__inv_2
Xoutput461 _5658_/B VGND VGND VPWR VPWR alu_result_out[12] sky130_fd_sc_hd__clkdlybuf4s25_1
XFILLER_59_300 VGND VGND VPWR VPWR sky130_fd_sc_hd__decap_3
XFILLER_87_620 VGND VGND VPWR VPWR sky130_fd_sc_hd__decap_3
Xoutput494 _3525_/B VGND VGND VPWR VPWR instruction_out[14] sky130_fd_sc_hd__clkdlybuf4s25_1
Xoutput483 place112/X VGND VGND VPWR VPWR alu_result_out[3] sky130_fd_sc_hd__clkdlybuf4s25_1
Xoutput472 _5663_/C VGND VGND VPWR VPWR alu_result_out[22] sky130_fd_sc_hd__clkdlybuf4s25_1
XTAP_TAPCELL_ROW_74_1090 VGND VPWR sky130_fd_sc_hd__tapvpwrvgnd_1
XFILLER_86_141 VGND VGND VPWR VPWR sky130_fd_sc_hd__decap_3
X_7119_ _7380_/CLK _7119_/D _6399_/Y VGND VGND VPWR VPWR _7119_/Q sky130_fd_sc_hd__dfrtp_2
XFILLER_101_452 VGND VGND VPWR VPWR sky130_fd_sc_hd__decap_3
XFILLER_86_152 VGND VGND VPWR VPWR sky130_fd_sc_hd__decap_3
XFILLER_101_496 VGND VGND VPWR VPWR sky130_fd_sc_hd__decap_3
XFILLER_86_185 VGND VGND VPWR VPWR sky130_fd_sc_hd__decap_3
XFILLER_74_358 VGND VGND VPWR VPWR sky130_fd_sc_hd__decap_3
XFILLER_103_73 VGND VGND VPWR VPWR sky130_fd_sc_hd__fill_2
XFILLER_15_414 VGND VGND VPWR VPWR sky130_fd_sc_hd__decap_3
XFILLER_15_436 VGND VGND VPWR VPWR sky130_fd_sc_hd__decap_3
XFILLER_27_274 VGND VGND VPWR VPWR sky130_fd_sc_hd__decap_3
XFILLER_42_200 VGND VGND VPWR VPWR sky130_fd_sc_hd__decap_3
XFILLER_63_11 VGND VGND VPWR VPWR sky130_fd_sc_hd__fill_1
XFILLER_82_380 VGND VGND VPWR VPWR sky130_fd_sc_hd__decap_3
XFILLER_103_95 VGND VGND VPWR VPWR sky130_fd_sc_hd__fill_2
XFILLER_15_458 VGND VGND VPWR VPWR sky130_fd_sc_hd__decap_3
XFILLER_42_233 VGND VGND VPWR VPWR sky130_fd_sc_hd__decap_3
XFILLER_70_542 VGND VGND VPWR VPWR sky130_fd_sc_hd__decap_3
XFILLER_70_575 VGND VGND VPWR VPWR sky130_fd_sc_hd__decap_3
XFILLER_11_620 VGND VGND VPWR VPWR sky130_fd_sc_hd__decap_3
XFILLER_23_491 VGND VGND VPWR VPWR sky130_fd_sc_hd__fill_2
XFILLER_10_163 VGND VGND VPWR VPWR sky130_fd_sc_hd__decap_3
XFILLER_10_174 VGND VGND VPWR VPWR sky130_fd_sc_hd__decap_3
XFILLER_7_635 VGND VGND VPWR VPWR sky130_fd_sc_hd__decap_3
XTAP_TAPCELL_ROW_77_1119 VGND VPWR sky130_fd_sc_hd__tapvpwrvgnd_1
XFILLER_12_81 VGND VGND VPWR VPWR sky130_fd_sc_hd__decap_3
XFILLER_6_178 VGND VGND VPWR VPWR sky130_fd_sc_hd__decap_3
XFILLER_69_108 VGND VGND VPWR VPWR sky130_fd_sc_hd__decap_3
XFILLER_97_417 VGND VGND VPWR VPWR sky130_fd_sc_hd__decap_3
XFILLER_78_620 VGND VGND VPWR VPWR sky130_fd_sc_hd__decap_3
XFILLER_88_85 VGND VGND VPWR VPWR sky130_fd_sc_hd__fill_1
XFILLER_38_528 VGND VGND VPWR VPWR sky130_fd_sc_hd__decap_3
XFILLER_77_152 VGND VGND VPWR VPWR sky130_fd_sc_hd__decap_3
XFILLER_93_601 VGND VGND VPWR VPWR sky130_fd_sc_hd__decap_3
XFILLER_93_623 VGND VGND VPWR VPWR sky130_fd_sc_hd__decap_3
XFILLER_77_196 VGND VGND VPWR VPWR sky130_fd_sc_hd__decap_3
XTAP_TAPCELL_ROW_88_1248 VGND VPWR sky130_fd_sc_hd__tapvpwrvgnd_1
XFILLER_65_369 VGND VGND VPWR VPWR sky130_fd_sc_hd__fill_1
XFILLER_80_306 VGND VGND VPWR VPWR sky130_fd_sc_hd__fill_2
XFILLER_92_144 VGND VGND VPWR VPWR sky130_fd_sc_hd__decap_3
XFILLER_18_263 VGND VGND VPWR VPWR sky130_fd_sc_hd__decap_3
XFILLER_61_520 VGND VGND VPWR VPWR sky130_fd_sc_hd__decap_3
XFILLER_80_339 VGND VGND VPWR VPWR sky130_fd_sc_hd__fill_2
XFILLER_92_188 VGND VGND VPWR VPWR sky130_fd_sc_hd__decap_3
XFILLER_33_222 VGND VGND VPWR VPWR sky130_fd_sc_hd__fill_2
XFILLER_33_244 VGND VGND VPWR VPWR sky130_fd_sc_hd__decap_3
XFILLER_73_391 VGND VGND VPWR VPWR sky130_fd_sc_hd__fill_1
X_4820_ _5156_/S _5634_/B VGND VGND VPWR VPWR _5010_/A sky130_fd_sc_hd__nand2_2
XTAP_TAPCELL_ROW_44_740 VGND VPWR sky130_fd_sc_hd__tapvpwrvgnd_1
XTAP_TAPCELL_ROW_16_420 VGND VPWR sky130_fd_sc_hd__tapvpwrvgnd_1
XFILLER_14_491 VGND VGND VPWR VPWR sky130_fd_sc_hd__decap_3
X_4751_ _4751_/A _4751_/B VGND VGND VPWR VPWR _4751_/Y sky130_fd_sc_hd__nand2_2
X_4682_ _4928_/B _4682_/B _4960_/B VGND VGND VPWR VPWR _4943_/A sky130_fd_sc_hd__and3b_2
X_3702_ hold986/X _4799_/A _3701_/X VGND VGND VPWR VPWR _7401_/D sky130_fd_sc_hd__o21a_2
X_6421_ _6650_/A VGND VGND VPWR VPWR _6421_/Y sky130_fd_sc_hd__inv_2
X_3633_ _3636_/A _5114_/A _5033_/B2 _3630_/A VGND VGND VPWR VPWR _3633_/Y sky130_fd_sc_hd__a22oi_2
XTAP_TAPCELL_ROW_99_1377 VGND VPWR sky130_fd_sc_hd__tapvpwrvgnd_1
XFILLER_108_29 VGND VGND VPWR VPWR sky130_fd_sc_hd__decap_3
X_6352_ _6677_/A VGND VGND VPWR VPWR _6352_/Y sky130_fd_sc_hd__inv_2
X_3564_ _5118_/A _5362_/C VGND VGND VPWR VPWR _3564_/X sky130_fd_sc_hd__and2_2
X_6283_ _6397_/A VGND VGND VPWR VPWR _6283_/Y sky130_fd_sc_hd__inv_2
X_3495_ _7028_/Q _3562_/A _3494_/X VGND VGND VPWR VPWR _3495_/X sky130_fd_sc_hd__a21o_2
XFILLER_69_620 VGND VGND VPWR VPWR sky130_fd_sc_hd__decap_3
XFILLER_88_417 VGND VGND VPWR VPWR sky130_fd_sc_hd__decap_3
X_5234_ _5234_/A0 _4734_/X _5274_/S VGND VGND VPWR VPWR _7213_/D sky130_fd_sc_hd__mux2_2
XFILLER_102_238 VGND VGND VPWR VPWR sky130_fd_sc_hd__fill_2
X_5165_ _5165_/A _5186_/B VGND VGND VPWR VPWR _7245_/D sky130_fd_sc_hd__and2_2
XFILLER_29_517 VGND VGND VPWR VPWR sky130_fd_sc_hd__fill_2
XFILLER_68_141 VGND VGND VPWR VPWR sky130_fd_sc_hd__decap_3
X_4116_ _7076_/Q _4265_/B VGND VGND VPWR VPWR _4117_/C sky130_fd_sc_hd__or2_2
XFILLER_96_450 VGND VGND VPWR VPWR sky130_fd_sc_hd__decap_3
XFILLER_68_174 VGND VGND VPWR VPWR sky130_fd_sc_hd__decap_3
XFILLER_83_111 VGND VGND VPWR VPWR sky130_fd_sc_hd__fill_1
XFILLER_83_122 VGND VGND VPWR VPWR sky130_fd_sc_hd__decap_3
XFILLER_84_645 VGND VGND VPWR VPWR sky130_fd_sc_hd__decap_3
XFILLER_37_561 VGND VGND VPWR VPWR sky130_fd_sc_hd__decap_3
X_4047_ _7245_/Q _4414_/A2 _4422_/A2 _7027_/Q _4046_/X VGND VGND VPWR VPWR _4047_/X
+ sky130_fd_sc_hd__a221o_2
XFILLER_24_200 VGND VGND VPWR VPWR sky130_fd_sc_hd__decap_3
XFILLER_71_317 VGND VGND VPWR VPWR sky130_fd_sc_hd__fill_2
XFILLER_83_199 VGND VGND VPWR VPWR sky130_fd_sc_hd__decap_3
XTAP_TAPCELL_ROW_108_1484 VGND VPWR sky130_fd_sc_hd__tapvpwrvgnd_1
XTAP_TAPCELL_ROW_108_1473 VGND VPWR sky130_fd_sc_hd__tapvpwrvgnd_1
XFILLER_24_233 VGND VGND VPWR VPWR sky130_fd_sc_hd__decap_3
XFILLER_12_417 VGND VGND VPWR VPWR sky130_fd_sc_hd__decap_3
X_4949_ _4967_/A _4967_/B VGND VGND VPWR VPWR _4949_/Y sky130_fd_sc_hd__nand2_2
XFILLER_20_472 VGND VGND VPWR VPWR sky130_fd_sc_hd__decap_3
X_6619_ _6619_/A VGND VGND VPWR VPWR _6619_/Y sky130_fd_sc_hd__inv_2
XTAP_TAPCELL_ROW_22_489 VGND VPWR sky130_fd_sc_hd__tapvpwrvgnd_1
XFILLER_4_616 VGND VGND VPWR VPWR sky130_fd_sc_hd__decap_3
XFILLER_106_533 VGND VGND VPWR VPWR sky130_fd_sc_hd__fill_1
XFILLER_58_77 VGND VGND VPWR VPWR sky130_fd_sc_hd__decap_3
XFILLER_58_99 VGND VGND VPWR VPWR sky130_fd_sc_hd__decap_3
XFILLER_101_293 VGND VGND VPWR VPWR sky130_fd_sc_hd__decap_3
XFILLER_62_306 VGND VGND VPWR VPWR sky130_fd_sc_hd__fill_2
XFILLER_74_133 VGND VGND VPWR VPWR sky130_fd_sc_hd__decap_3
XFILLER_74_144 VGND VGND VPWR VPWR sky130_fd_sc_hd__decap_3
XFILLER_90_604 VGND VGND VPWR VPWR sky130_fd_sc_hd__decap_3
XFILLER_28_583 VGND VGND VPWR VPWR sky130_fd_sc_hd__decap_3
XFILLER_62_317 VGND VGND VPWR VPWR sky130_fd_sc_hd__decap_3
XFILLER_74_177 VGND VGND VPWR VPWR sky130_fd_sc_hd__decap_3
XTAP_TAPCELL_ROW_58_898 VGND VPWR sky130_fd_sc_hd__tapvpwrvgnd_1
XFILLER_15_266 VGND VGND VPWR VPWR sky130_fd_sc_hd__decap_3
XFILLER_30_203 VGND VGND VPWR VPWR sky130_fd_sc_hd__decap_3
XFILLER_43_564 VGND VGND VPWR VPWR sky130_fd_sc_hd__decap_3
XFILLER_70_350 VGND VGND VPWR VPWR sky130_fd_sc_hd__decap_3
XFILLER_15_299 VGND VGND VPWR VPWR sky130_fd_sc_hd__decap_3
XFILLER_70_383 VGND VGND VPWR VPWR sky130_fd_sc_hd__decap_3
XTAP_TAPCELL_ROW_83_1189 VGND VPWR sky130_fd_sc_hd__tapvpwrvgnd_1
XTAP_TAPCELL_ROW_41_710 VGND VPWR sky130_fd_sc_hd__tapvpwrvgnd_1
XFILLER_30_269 VGND VGND VPWR VPWR sky130_fd_sc_hd__fill_2
XFILLER_11_461 VGND VGND VPWR VPWR sky130_fd_sc_hd__decap_3
XFILLER_7_421 VGND VGND VPWR VPWR sky130_fd_sc_hd__decap_3
XFILLER_99_51 VGND VGND VPWR VPWR sky130_fd_sc_hd__decap_3
XFILLER_99_95 VGND VGND VPWR VPWR sky130_fd_sc_hd__decap_3
XFILLER_97_225 VGND VGND VPWR VPWR sky130_fd_sc_hd__decap_3
XFILLER_97_203 VGND VGND VPWR VPWR sky130_fd_sc_hd__decap_3
XFILLER_2_192 VGND VGND VPWR VPWR sky130_fd_sc_hd__fill_1
XFILLER_78_472 VGND VGND VPWR VPWR sky130_fd_sc_hd__decap_3
XFILLER_85_409 VGND VGND VPWR VPWR sky130_fd_sc_hd__decap_3
XFILLER_17_3 VGND VGND VPWR VPWR sky130_fd_sc_hd__decap_3
XFILLER_38_325 VGND VGND VPWR VPWR sky130_fd_sc_hd__decap_3
XFILLER_65_122 VGND VGND VPWR VPWR sky130_fd_sc_hd__decap_3
XFILLER_66_634 VGND VGND VPWR VPWR sky130_fd_sc_hd__decap_3
XFILLER_66_645 VGND VGND VPWR VPWR sky130_fd_sc_hd__decap_3
XFILLER_81_615 VGND VGND VPWR VPWR sky130_fd_sc_hd__fill_1
X_6970_ clkload5/A _6970_/D VGND VGND VPWR VPWR _6970_/Q sky130_fd_sc_hd__dfxtp_2
XFILLER_53_328 VGND VGND VPWR VPWR sky130_fd_sc_hd__fill_2
XFILLER_65_199 VGND VGND VPWR VPWR sky130_fd_sc_hd__fill_1
XFILLER_19_594 VGND VGND VPWR VPWR sky130_fd_sc_hd__decap_3
XFILLER_34_542 VGND VGND VPWR VPWR sky130_fd_sc_hd__decap_3
XFILLER_46_391 VGND VGND VPWR VPWR sky130_fd_sc_hd__decap_3
XFILLER_34_564 VGND VGND VPWR VPWR sky130_fd_sc_hd__decap_3
XFILLER_80_169 VGND VGND VPWR VPWR sky130_fd_sc_hd__decap_3
XFILLER_21_225 VGND VGND VPWR VPWR sky130_fd_sc_hd__decap_3
X_4803_ _7003_/Q _4802_/X _4677_/B _5667_/A VGND VGND VPWR VPWR _4804_/B sky130_fd_sc_hd__o211ai_2
X_4734_ _4726_/X _4729_/Y _7007_/D _5061_/S VGND VGND VPWR VPWR _4734_/X sky130_fd_sc_hd__o22a_2
X_4665_ _7005_/Q _5633_/B VGND VGND VPWR VPWR _4665_/X sky130_fd_sc_hd__or2_2
X_7384_ _7387_/CLK _7384_/D _6664_/Y VGND VGND VPWR VPWR _7384_/Q sky130_fd_sc_hd__dfrtp_2
Xhold900 _7096_/Q VGND VGND VPWR VPWR _7096_/D sky130_fd_sc_hd__dlygate4sd3_1
Xhold911 _6687_/Q VGND VGND VPWR VPWR hold911/X sky130_fd_sc_hd__dlygate4sd3_1
Xhold922 _6715_/Q VGND VGND VPWR VPWR hold922/X sky130_fd_sc_hd__dlygate4sd3_1
X_6404_ _6630_/A VGND VGND VPWR VPWR _6404_/Y sky130_fd_sc_hd__inv_2
X_3616_ _4614_/C _3616_/B VGND VGND VPWR VPWR _3616_/Y sky130_fd_sc_hd__nand2_2
XFILLER_1_608 VGND VGND VPWR VPWR sky130_fd_sc_hd__decap_3
Xhold933 _6700_/Q VGND VGND VPWR VPWR hold933/X sky130_fd_sc_hd__dlygate4sd3_1
Xhold955 _7042_/Q VGND VGND VPWR VPWR hold955/X sky130_fd_sc_hd__dlygate4sd3_1
Xhold944 _7043_/Q VGND VGND VPWR VPWR hold944/X sky130_fd_sc_hd__dlygate4sd3_1
X_6335_ _6625_/A VGND VGND VPWR VPWR _6335_/Y sky130_fd_sc_hd__inv_2
X_3547_ _3547_/A _3547_/B VGND VGND VPWR VPWR _3547_/Y sky130_fd_sc_hd__nand2_2
XFILLER_88_214 VGND VGND VPWR VPWR sky130_fd_sc_hd__decap_3
Xhold988 _7017_/Q VGND VGND VPWR VPWR _5621_/A sky130_fd_sc_hd__dlygate4sd3_1
Xhold977 _7279_/Q VGND VGND VPWR VPWR hold977/X sky130_fd_sc_hd__dlygate4sd3_1
Xhold966 _7011_/Q VGND VGND VPWR VPWR _5634_/A sky130_fd_sc_hd__dlygate4sd3_1
Xhold999 _7045_/Q VGND VGND VPWR VPWR hold999/X sky130_fd_sc_hd__dlygate4sd3_1
X_6266_ _6668_/A VGND VGND VPWR VPWR _6266_/Y sky130_fd_sc_hd__inv_2
X_3478_ _7216_/Q _4353_/A2 _4534_/S _7029_/Q _3477_/X VGND VGND VPWR VPWR _3478_/X
+ sky130_fd_sc_hd__a221o_2
XFILLER_29_303 VGND VGND VPWR VPWR sky130_fd_sc_hd__decap_3
XFILLER_57_612 VGND VGND VPWR VPWR sky130_fd_sc_hd__decap_3
XFILLER_69_461 VGND VGND VPWR VPWR sky130_fd_sc_hd__fill_1
X_5217_ _5217_/A _5225_/B VGND VGND VPWR VPWR _7220_/D sky130_fd_sc_hd__and2_2
XFILLER_29_314 VGND VGND VPWR VPWR sky130_fd_sc_hd__decap_3
XFILLER_56_111 VGND VGND VPWR VPWR sky130_fd_sc_hd__decap_3
XFILLER_57_623 VGND VGND VPWR VPWR sky130_fd_sc_hd__decap_3
XFILLER_69_483 VGND VGND VPWR VPWR sky130_fd_sc_hd__decap_3
X_5148_ _5144_/A _5071_/A _4764_/B _3540_/X VGND VGND VPWR VPWR _5148_/X sky130_fd_sc_hd__a211o_2
XFILLER_29_369 VGND VGND VPWR VPWR sky130_fd_sc_hd__decap_3
XFILLER_56_144 VGND VGND VPWR VPWR sky130_fd_sc_hd__fill_1
XFILLER_84_464 VGND VGND VPWR VPWR sky130_fd_sc_hd__decap_3
X_5079_ _5156_/S _6987_/D _5078_/X VGND VGND VPWR VPWR _5079_/X sky130_fd_sc_hd__o21a_2
XFILLER_56_177 VGND VGND VPWR VPWR sky130_fd_sc_hd__decap_3
XFILLER_71_158 VGND VGND VPWR VPWR sky130_fd_sc_hd__decap_3
XTAP_TAPCELL_ROW_55_868 VGND VPWR sky130_fd_sc_hd__tapvpwrvgnd_1
XTAP_TAPCELL_ROW_27_548 VGND VPWR sky130_fd_sc_hd__tapvpwrvgnd_1
XFILLER_12_203 VGND VGND VPWR VPWR sky130_fd_sc_hd__decap_3
XFILLER_71_169 VGND VGND VPWR VPWR sky130_fd_sc_hd__decap_3
XFILLER_12_236 VGND VGND VPWR VPWR sky130_fd_sc_hd__fill_1
XFILLER_40_545 VGND VGND VPWR VPWR sky130_fd_sc_hd__decap_3
XFILLER_100_52 VGND VGND VPWR VPWR sky130_fd_sc_hd__decap_3
XFILLER_12_269 VGND VGND VPWR VPWR sky130_fd_sc_hd__decap_3
XFILLER_40_589 VGND VGND VPWR VPWR sky130_fd_sc_hd__decap_3
XFILLER_5_18 VGND VGND VPWR VPWR sky130_fd_sc_hd__decap_3
XFILLER_106_374 VGND VGND VPWR VPWR sky130_fd_sc_hd__decap_3
XFILLER_79_214 VGND VGND VPWR VPWR sky130_fd_sc_hd__decap_3
XFILLER_106_396 VGND VGND VPWR VPWR sky130_fd_sc_hd__decap_3
XFILLER_79_236 VGND VGND VPWR VPWR sky130_fd_sc_hd__fill_1
XFILLER_79_247 VGND VGND VPWR VPWR sky130_fd_sc_hd__decap_3
XFILLER_48_634 VGND VGND VPWR VPWR sky130_fd_sc_hd__decap_3
XFILLER_48_645 VGND VGND VPWR VPWR sky130_fd_sc_hd__decap_3
XFILLER_75_420 VGND VGND VPWR VPWR sky130_fd_sc_hd__decap_3
XFILLER_47_155 VGND VGND VPWR VPWR sky130_fd_sc_hd__decap_3
XFILLER_18_80 VGND VGND VPWR VPWR sky130_fd_sc_hd__decap_3
XFILLER_63_626 VGND VGND VPWR VPWR sky130_fd_sc_hd__decap_3
XFILLER_75_475 VGND VGND VPWR VPWR sky130_fd_sc_hd__decap_3
XTAP_TAPCELL_ROW_85_1207 VGND VPWR sky130_fd_sc_hd__tapvpwrvgnd_1
XFILLER_16_586 VGND VGND VPWR VPWR sky130_fd_sc_hd__fill_2
XFILLER_31_589 VGND VGND VPWR VPWR sky130_fd_sc_hd__decap_3
XFILLER_7_240 VGND VGND VPWR VPWR sky130_fd_sc_hd__decap_3
XFILLER_7_273 VGND VGND VPWR VPWR sky130_fd_sc_hd__decap_3
X_4450_ _4451_/A _4451_/B VGND VGND VPWR VPWR _4452_/A sky130_fd_sc_hd__and2_2
XTAP_TAPCELL_ROW_96_1336 VGND VPWR sky130_fd_sc_hd__tapvpwrvgnd_1
X_4381_ _4381_/A _4381_/B VGND VGND VPWR VPWR _4967_/B sky130_fd_sc_hd__nand2_2
X_3401_ _4467_/A _3519_/B _5294_/A _3330_/Y VGND VGND VPWR VPWR _3401_/X sky130_fd_sc_hd__a31o_4
X_3332_ _4467_/A _3332_/B VGND VGND VPWR VPWR _3341_/A sky130_fd_sc_hd__nand2_2
XFILLER_98_523 VGND VGND VPWR VPWR sky130_fd_sc_hd__fill_1
XFILLER_98_512 VGND VGND VPWR VPWR sky130_fd_sc_hd__fill_2
XFILLER_98_545 VGND VGND VPWR VPWR sky130_fd_sc_hd__decap_3
XFILLER_100_539 VGND VGND VPWR VPWR sky130_fd_sc_hd__decap_3
XFILLER_39_612 VGND VGND VPWR VPWR sky130_fd_sc_hd__decap_3
XFILLER_39_623 VGND VGND VPWR VPWR sky130_fd_sc_hd__decap_3
XFILLER_85_228 VGND VGND VPWR VPWR sky130_fd_sc_hd__decap_3
X_5002_ _5003_/A _5003_/B _3548_/X VGND VGND VPWR VPWR _5002_/Y sky130_fd_sc_hd__a21oi_2
XFILLER_38_133 VGND VGND VPWR VPWR sky130_fd_sc_hd__decap_3
XFILLER_38_144 VGND VGND VPWR VPWR sky130_fd_sc_hd__decap_3
XFILLER_66_453 VGND VGND VPWR VPWR sky130_fd_sc_hd__decap_3
XFILLER_38_188 VGND VGND VPWR VPWR sky130_fd_sc_hd__decap_3
XFILLER_54_626 VGND VGND VPWR VPWR sky130_fd_sc_hd__decap_3
XFILLER_81_412 VGND VGND VPWR VPWR sky130_fd_sc_hd__decap_3
XFILLER_19_391 VGND VGND VPWR VPWR sky130_fd_sc_hd__fill_1
XFILLER_53_125 VGND VGND VPWR VPWR sky130_fd_sc_hd__decap_3
XFILLER_53_147 VGND VGND VPWR VPWR sky130_fd_sc_hd__decap_3
XFILLER_93_294 VGND VGND VPWR VPWR sky130_fd_sc_hd__decap_3
X_6953_ _6965_/CLK _6953_/D VGND VGND VPWR VPWR _6953_/Q sky130_fd_sc_hd__dfxtp_2
XFILLER_34_350 VGND VGND VPWR VPWR sky130_fd_sc_hd__decap_3
XFILLER_53_169 VGND VGND VPWR VPWR sky130_fd_sc_hd__decap_3
Xclkbuf_3_5__f_clk clkbuf_0_clk/X VGND VGND VPWR VPWR clkload1/A sky130_fd_sc_hd__clkbuf_16
X_6884_ _6968_/CLK _6884_/D VGND VGND VPWR VPWR _6884_/Q sky130_fd_sc_hd__dfxtp_2
XTAP_TAPCELL_ROW_52_827 VGND VPWR sky130_fd_sc_hd__tapvpwrvgnd_1
XTAP_TAPCELL_ROW_24_507 VGND VPWR sky130_fd_sc_hd__tapvpwrvgnd_1
XTAP_TAPCELL_ROW_105_1443 VGND VPWR sky130_fd_sc_hd__tapvpwrvgnd_1
XFILLER_14_27 VGND VGND VPWR VPWR sky130_fd_sc_hd__fill_1
XTAP_TAPCELL_ROW_52_838 VGND VPWR sky130_fd_sc_hd__tapvpwrvgnd_1
XFILLER_61_191 VGND VGND VPWR VPWR sky130_fd_sc_hd__decap_3
XFILLER_22_589 VGND VGND VPWR VPWR sky130_fd_sc_hd__decap_3
XFILLER_108_617 VGND VGND VPWR VPWR sky130_fd_sc_hd__decap_3
X_5697_ _7354_/Q hold917/X _5697_/S VGND VGND VPWR VPWR _6698_/D sky130_fd_sc_hd__mux2_2
X_4648_ _4648_/A VGND VGND VPWR VPWR _4648_/Y sky130_fd_sc_hd__inv_2
Xhold730 _6926_/Q VGND VGND VPWR VPWR _6926_/D sky130_fd_sc_hd__dlygate4sd3_1
X_7367_ _7406_/CLK _7367_/D _6647_/Y VGND VGND VPWR VPWR _7367_/Q sky130_fd_sc_hd__dfrtp_2
Xhold741 _6824_/Q VGND VGND VPWR VPWR _6824_/D sky130_fd_sc_hd__dlygate4sd3_1
Xhold752 _6870_/Q VGND VGND VPWR VPWR _6870_/D sky130_fd_sc_hd__dlygate4sd3_1
Xhold763 _6726_/Q VGND VGND VPWR VPWR _6726_/D sky130_fd_sc_hd__dlygate4sd3_1
X_4579_ _4579_/A _4589_/B VGND VGND VPWR VPWR _7291_/D sky130_fd_sc_hd__and2_2
XFILLER_103_311 VGND VGND VPWR VPWR sky130_fd_sc_hd__decap_3
XFILLER_1_449 VGND VGND VPWR VPWR sky130_fd_sc_hd__fill_2
X_7298_ _7366_/CLK _7298_/D _6578_/Y VGND VGND VPWR VPWR _7298_/Q sky130_fd_sc_hd__dfrtp_2
Xhold774 _6938_/Q VGND VGND VPWR VPWR _6938_/D sky130_fd_sc_hd__dlygate4sd3_1
Xhold785 _6769_/Q VGND VGND VPWR VPWR _6769_/D sky130_fd_sc_hd__dlygate4sd3_1
Xhold796 _6928_/Q VGND VGND VPWR VPWR _6928_/D sky130_fd_sc_hd__dlygate4sd3_1
X_6318_ _6669_/A VGND VGND VPWR VPWR _6318_/Y sky130_fd_sc_hd__inv_2
XFILLER_103_355 VGND VGND VPWR VPWR sky130_fd_sc_hd__fill_1
XFILLER_76_206 VGND VGND VPWR VPWR sky130_fd_sc_hd__decap_3
XFILLER_89_589 VGND VGND VPWR VPWR sky130_fd_sc_hd__fill_1
XFILLER_103_399 VGND VGND VPWR VPWR sky130_fd_sc_hd__decap_3
XFILLER_91_209 VGND VGND VPWR VPWR sky130_fd_sc_hd__decap_3
XFILLER_29_166 VGND VGND VPWR VPWR sky130_fd_sc_hd__fill_2
XFILLER_45_626 VGND VGND VPWR VPWR sky130_fd_sc_hd__decap_3
XFILLER_57_497 VGND VGND VPWR VPWR sky130_fd_sc_hd__decap_3
XFILLER_84_272 VGND VGND VPWR VPWR sky130_fd_sc_hd__decap_3
XTAP_TAPCELL_ROW_4_276 VGND VPWR sky130_fd_sc_hd__tapvpwrvgnd_1
XFILLER_29_199 VGND VGND VPWR VPWR sky130_fd_sc_hd__decap_3
XFILLER_44_147 VGND VGND VPWR VPWR sky130_fd_sc_hd__decap_3
XFILLER_60_618 VGND VGND VPWR VPWR sky130_fd_sc_hd__decap_3
XFILLER_72_467 VGND VGND VPWR VPWR sky130_fd_sc_hd__decap_3
XFILLER_52_180 VGND VGND VPWR VPWR sky130_fd_sc_hd__decap_3
XFILLER_71_22 VGND VGND VPWR VPWR sky130_fd_sc_hd__decap_3
XFILLER_13_567 VGND VGND VPWR VPWR sky130_fd_sc_hd__decap_3
XTAP_TAPCELL_ROW_80_1159 VGND VPWR sky130_fd_sc_hd__tapvpwrvgnd_1
XFILLER_9_505 VGND VGND VPWR VPWR sky130_fd_sc_hd__decap_3
XFILLER_9_549 VGND VGND VPWR VPWR sky130_fd_sc_hd__decap_3
XFILLER_40_397 VGND VGND VPWR VPWR sky130_fd_sc_hd__decap_3
XFILLER_4_232 VGND VGND VPWR VPWR sky130_fd_sc_hd__decap_3
XTAP_TAPCELL_ROW_91_1277 VGND VPWR sky130_fd_sc_hd__tapvpwrvgnd_1
XFILLER_67_217 VGND VGND VPWR VPWR sky130_fd_sc_hd__fill_2
XFILLER_67_239 VGND VGND VPWR VPWR sky130_fd_sc_hd__fill_2
XFILLER_96_85 VGND VGND VPWR VPWR sky130_fd_sc_hd__decap_3
XFILLER_96_74 VGND VGND VPWR VPWR sky130_fd_sc_hd__decap_3
XFILLER_96_63 VGND VGND VPWR VPWR sky130_fd_sc_hd__fill_2
XFILLER_95_548 VGND VGND VPWR VPWR sky130_fd_sc_hd__decap_3
XFILLER_36_626 VGND VGND VPWR VPWR sky130_fd_sc_hd__decap_3
XFILLER_48_475 VGND VGND VPWR VPWR sky130_fd_sc_hd__fill_1
XFILLER_75_250 VGND VGND VPWR VPWR sky130_fd_sc_hd__decap_3
XFILLER_35_136 VGND VGND VPWR VPWR sky130_fd_sc_hd__decap_3
Xplace401 _4501_/S VGND VGND VPWR VPWR _4478_/S sky130_fd_sc_hd__buf_2
Xplace412 _4354_/B1 VGND VGND VPWR VPWR _4399_/A2 sky130_fd_sc_hd__buf_2
XPHY_EDGE_ROW_11_Left_120 VGND VGND VPWR VPWR sky130_fd_sc_hd__decap_3
XFILLER_16_350 VGND VGND VPWR VPWR sky130_fd_sc_hd__decap_3
XFILLER_51_629 VGND VGND VPWR VPWR sky130_fd_sc_hd__decap_3
XFILLER_63_478 VGND VGND VPWR VPWR sky130_fd_sc_hd__decap_3
XFILLER_90_242 VGND VGND VPWR VPWR sky130_fd_sc_hd__fill_1
Xplace423 _3989_/S VGND VGND VPWR VPWR _3958_/S sky130_fd_sc_hd__buf_2
Xplace434 _3341_/A VGND VGND VPWR VPWR _5156_/S sky130_fd_sc_hd__buf_2
Xplace445 _7010_/Q VGND VGND VPWR VPWR _7010_/D sky130_fd_sc_hd__buf_2
Xplace456 _3353_/B VGND VGND VPWR VPWR _5129_/B sky130_fd_sc_hd__buf_2
XFILLER_50_139 VGND VGND VPWR VPWR sky130_fd_sc_hd__fill_1
XFILLER_43_180 VGND VGND VPWR VPWR sky130_fd_sc_hd__decap_3
X_3881_ _6724_/Q _3881_/A2 _3881_/B1 _6719_/Q VGND VGND VPWR VPWR _3881_/X sky130_fd_sc_hd__a22o_2
XFILLER_84_3 VGND VGND VPWR VPWR sky130_fd_sc_hd__decap_3
XTAP_TAPCELL_ROW_100_1384 VGND VPWR sky130_fd_sc_hd__tapvpwrvgnd_1
X_7221_ _7349_/CLK _7221_/D _6501_/Y VGND VGND VPWR VPWR _7221_/Q sky130_fd_sc_hd__dfrtp_2
X_4433_ _7239_/Q _4433_/B VGND VGND VPWR VPWR _4433_/X sky130_fd_sc_hd__and2_2
X_7152_ _7376_/CLK _7152_/D _6432_/Y VGND VGND VPWR VPWR _7152_/Q sky130_fd_sc_hd__dfrtp_2
X_4364_ _4364_/A _4364_/B VGND VGND VPWR VPWR _4364_/Y sky130_fd_sc_hd__nor2_2
XFILLER_58_206 VGND VGND VPWR VPWR sky130_fd_sc_hd__decap_3
X_7083_ _7083_/CLK _7083_/D _6363_/Y VGND VGND VPWR VPWR _7083_/Q sky130_fd_sc_hd__dfrtp_2
X_4295_ _3607_/B _4295_/B VGND VGND VPWR VPWR _4295_/X sky130_fd_sc_hd__and2b_2
XFILLER_100_358 VGND VGND VPWR VPWR sky130_fd_sc_hd__decap_3
XFILLER_27_615 VGND VGND VPWR VPWR sky130_fd_sc_hd__fill_1
XFILLER_27_626 VGND VGND VPWR VPWR sky130_fd_sc_hd__decap_3
XFILLER_39_475 VGND VGND VPWR VPWR sky130_fd_sc_hd__decap_3
XFILLER_66_261 VGND VGND VPWR VPWR sky130_fd_sc_hd__decap_3
XFILLER_26_114 VGND VGND VPWR VPWR sky130_fd_sc_hd__decap_3
XFILLER_81_220 VGND VGND VPWR VPWR sky130_fd_sc_hd__decap_3
XFILLER_81_231 VGND VGND VPWR VPWR sky130_fd_sc_hd__decap_3
XFILLER_94_592 VGND VGND VPWR VPWR sky130_fd_sc_hd__decap_3
XTAP_TAPCELL_ROW_1_246 VGND VPWR sky130_fd_sc_hd__tapvpwrvgnd_1
XFILLER_14_309 VGND VGND VPWR VPWR sky130_fd_sc_hd__decap_3
XFILLER_26_147 VGND VGND VPWR VPWR sky130_fd_sc_hd__decap_3
XFILLER_26_158 VGND VGND VPWR VPWR sky130_fd_sc_hd__decap_3
XFILLER_42_618 VGND VGND VPWR VPWR sky130_fd_sc_hd__decap_3
XFILLER_54_467 VGND VGND VPWR VPWR sky130_fd_sc_hd__decap_3
X_6936_ clkload8/A _6936_/D VGND VGND VPWR VPWR _6936_/Q sky130_fd_sc_hd__dfxtp_2
XTAP_TAPCELL_ROW_65_985 VGND VPWR sky130_fd_sc_hd__tapvpwrvgnd_1
XTAP_TAPCELL_ROW_37_665 VGND VPWR sky130_fd_sc_hd__tapvpwrvgnd_1
X_6867_ clkload4/A _6867_/D VGND VGND VPWR VPWR _6867_/Q sky130_fd_sc_hd__dfxtp_2
XFILLER_22_386 VGND VGND VPWR VPWR sky130_fd_sc_hd__decap_3
X_6798_ _6965_/CLK _6798_/D VGND VGND VPWR VPWR _6798_/Q sky130_fd_sc_hd__dfxtp_2
XFILLER_10_537 VGND VGND VPWR VPWR sky130_fd_sc_hd__decap_3
XFILLER_41_36 VGND VGND VPWR VPWR sky130_fd_sc_hd__fill_2
XFILLER_6_508 VGND VGND VPWR VPWR sky130_fd_sc_hd__decap_3
XFILLER_104_620 VGND VGND VPWR VPWR sky130_fd_sc_hd__decap_3
XFILLER_1_213 VGND VGND VPWR VPWR sky130_fd_sc_hd__fill_1
XFILLER_89_320 VGND VGND VPWR VPWR sky130_fd_sc_hd__decap_3
XTAP_TAPCELL_ROW_9_335 VGND VPWR sky130_fd_sc_hd__tapvpwrvgnd_1
XFILLER_1_246 VGND VGND VPWR VPWR sky130_fd_sc_hd__decap_3
XFILLER_89_364 VGND VGND VPWR VPWR sky130_fd_sc_hd__decap_3
Xhold582 _6874_/Q VGND VGND VPWR VPWR _6874_/D sky130_fd_sc_hd__dlygate4sd3_1
Xhold593 _6825_/Q VGND VGND VPWR VPWR _6825_/D sky130_fd_sc_hd__dlygate4sd3_1
XFILLER_106_62 VGND VGND VPWR VPWR sky130_fd_sc_hd__decap_3
XFILLER_66_44 VGND VGND VPWR VPWR sky130_fd_sc_hd__fill_2
XFILLER_77_559 VGND VGND VPWR VPWR sky130_fd_sc_hd__fill_1
XFILLER_17_103 VGND VGND VPWR VPWR sky130_fd_sc_hd__decap_3
XFILLER_18_604 VGND VGND VPWR VPWR sky130_fd_sc_hd__decap_3
XFILLER_45_401 VGND VGND VPWR VPWR sky130_fd_sc_hd__decap_3
XFILLER_85_581 VGND VGND VPWR VPWR sky130_fd_sc_hd__decap_3
XFILLER_92_518 VGND VGND VPWR VPWR sky130_fd_sc_hd__fill_2
XFILLER_92_529 VGND VGND VPWR VPWR sky130_fd_sc_hd__decap_3
XFILLER_17_125 VGND VGND VPWR VPWR sky130_fd_sc_hd__fill_2
XFILLER_18_637 VGND VGND VPWR VPWR sky130_fd_sc_hd__decap_3
XFILLER_45_423 VGND VGND VPWR VPWR sky130_fd_sc_hd__decap_3
XFILLER_45_445 VGND VGND VPWR VPWR sky130_fd_sc_hd__decap_3
XFILLER_17_169 VGND VGND VPWR VPWR sky130_fd_sc_hd__decap_3
XFILLER_33_607 VGND VGND VPWR VPWR sky130_fd_sc_hd__decap_3
XFILLER_45_456 VGND VGND VPWR VPWR sky130_fd_sc_hd__decap_3
XFILLER_60_404 VGND VGND VPWR VPWR sky130_fd_sc_hd__decap_3
XFILLER_72_253 VGND VGND VPWR VPWR sky130_fd_sc_hd__fill_2
XFILLER_82_32 VGND VGND VPWR VPWR sky130_fd_sc_hd__decap_3
XFILLER_33_629 VGND VGND VPWR VPWR sky130_fd_sc_hd__decap_3
XFILLER_60_437 VGND VGND VPWR VPWR sky130_fd_sc_hd__decap_3
XFILLER_72_275 VGND VGND VPWR VPWR sky130_fd_sc_hd__decap_3
XFILLER_13_331 VGND VGND VPWR VPWR sky130_fd_sc_hd__fill_1
XFILLER_13_375 VGND VGND VPWR VPWR sky130_fd_sc_hd__decap_3
XFILLER_15_92 VGND VGND VPWR VPWR sky130_fd_sc_hd__decap_3
XFILLER_40_150 VGND VGND VPWR VPWR sky130_fd_sc_hd__fill_1
XFILLER_40_161 VGND VGND VPWR VPWR sky130_fd_sc_hd__decap_3
XFILLER_5_530 VGND VGND VPWR VPWR sky130_fd_sc_hd__fill_1
XTAP_TAPCELL_ROW_93_1306 VGND VPWR sky130_fd_sc_hd__tapvpwrvgnd_1
XFILLER_5_585 VGND VGND VPWR VPWR sky130_fd_sc_hd__decap_3
XFILLER_99_128 VGND VGND VPWR VPWR sky130_fd_sc_hd__decap_3
X_4080_ _4075_/X _4079_/X _4425_/A VGND VGND VPWR VPWR _4451_/B sky130_fd_sc_hd__o21ai_2
XFILLER_48_250 VGND VGND VPWR VPWR sky130_fd_sc_hd__fill_2
XFILLER_48_294 VGND VGND VPWR VPWR sky130_fd_sc_hd__fill_2
XFILLER_24_607 VGND VGND VPWR VPWR sky130_fd_sc_hd__decap_3
XFILLER_51_404 VGND VGND VPWR VPWR sky130_fd_sc_hd__decap_3
XFILLER_63_231 VGND VGND VPWR VPWR sky130_fd_sc_hd__decap_3
XFILLER_91_573 VGND VGND VPWR VPWR sky130_fd_sc_hd__fill_1
XFILLER_36_489 VGND VGND VPWR VPWR sky130_fd_sc_hd__fill_2
XFILLER_51_437 VGND VGND VPWR VPWR sky130_fd_sc_hd__decap_3
Xplace264 _4907_/Y VGND VGND VPWR VPWR _5657_/B sky130_fd_sc_hd__buf_2
X_4982_ _6992_/Q _4982_/B _5009_/A VGND VGND VPWR VPWR _4983_/C sky130_fd_sc_hd__or3_2
XTAP_TAPCELL_ROW_34_624 VGND VPWR sky130_fd_sc_hd__tapvpwrvgnd_1
XTAP_TAPCELL_ROW_102_1413 VGND VPWR sky130_fd_sc_hd__tapvpwrvgnd_1
XTAP_TAPCELL_ROW_102_1402 VGND VPWR sky130_fd_sc_hd__tapvpwrvgnd_1
XFILLER_16_191 VGND VGND VPWR VPWR sky130_fd_sc_hd__decap_3
XFILLER_32_640 VGND VGND VPWR VPWR sky130_fd_sc_hd__decap_3
Xplace297 _3651_/Y VGND VGND VPWR VPWR _3853_/A2 sky130_fd_sc_hd__buf_2
Xplace286 _3893_/B1 VGND VGND VPWR VPWR _3911_/A2 sky130_fd_sc_hd__buf_2
Xplace275 _3852_/A2 VGND VGND VPWR VPWR _3886_/A2 sky130_fd_sc_hd__buf_2
X_6721_ _6974_/CLK _6721_/D VGND VGND VPWR VPWR _6721_/Q sky130_fd_sc_hd__dfxtp_2
X_3933_ _7373_/Q _4476_/A0 _3943_/S VGND VGND VPWR VPWR _7373_/D sky130_fd_sc_hd__mux2_2
XTAP_TAPCELL_ROW_62_944 VGND VPWR sky130_fd_sc_hd__tapvpwrvgnd_1
X_6652_ _6652_/A VGND VGND VPWR VPWR _6652_/Y sky130_fd_sc_hd__inv_2
X_3864_ _3864_/A0 _3863_/X _3864_/S VGND VGND VPWR VPWR _7385_/D sky130_fd_sc_hd__mux2_2
X_6583_ _6619_/A VGND VGND VPWR VPWR _6583_/Y sky130_fd_sc_hd__inv_2
X_3795_ _6971_/Q _3913_/B1 _3881_/B1 _6721_/Q VGND VGND VPWR VPWR _3795_/X sky130_fd_sc_hd__a22o_2
XTAP_TAPCELL_ROW_14_392 VGND VPWR sky130_fd_sc_hd__tapvpwrvgnd_1
XFILLER_105_417 VGND VGND VPWR VPWR sky130_fd_sc_hd__decap_3
X_7204_ _7392_/CLK _7204_/D _6484_/Y VGND VGND VPWR VPWR _7204_/Q sky130_fd_sc_hd__dfrtp_2
X_4416_ _7368_/Q _4270_/B _4416_/B1 _7176_/Q _4415_/X VGND VGND VPWR VPWR _4416_/X
+ sky130_fd_sc_hd__a221o_2
X_7135_ _7362_/CLK _7135_/D _6415_/Y VGND VGND VPWR VPWR _7135_/Q sky130_fd_sc_hd__dfrtp_2
X_5396_ _5396_/A0 _4978_/X _5400_/S VGND VGND VPWR VPWR _7135_/D sky130_fd_sc_hd__mux2_2
XTAP_TAPCELL_ROW_6_305 VGND VPWR sky130_fd_sc_hd__tapvpwrvgnd_1
XFILLER_101_623 VGND VGND VPWR VPWR sky130_fd_sc_hd__decap_3
XFILLER_86_301 VGND VGND VPWR VPWR sky130_fd_sc_hd__decap_3
XFILLER_86_312 VGND VGND VPWR VPWR sky130_fd_sc_hd__fill_2
X_4347_ _7289_/Q _4495_/S _4346_/X _4347_/C1 VGND VGND VPWR VPWR _4347_/X sky130_fd_sc_hd__a211o_2
XFILLER_98_150 VGND VGND VPWR VPWR sky130_fd_sc_hd__decap_3
XFILLER_100_122 VGND VGND VPWR VPWR sky130_fd_sc_hd__decap_3
XFILLER_86_356 VGND VGND VPWR VPWR sky130_fd_sc_hd__fill_1
X_7066_ _7398_/CLK _7066_/D _6346_/Y VGND VGND VPWR VPWR _7066_/Q sky130_fd_sc_hd__dfrtp_2
X_4278_ _7286_/Q _4532_/S _4285_/B1 _7350_/Q _4248_/A VGND VGND VPWR VPWR _4278_/X
+ sky130_fd_sc_hd__a221o_2
XFILLER_98_194 VGND VGND VPWR VPWR sky130_fd_sc_hd__fill_2
XFILLER_100_144 VGND VGND VPWR VPWR sky130_fd_sc_hd__decap_3
XFILLER_67_570 VGND VGND VPWR VPWR sky130_fd_sc_hd__decap_3
XFILLER_86_378 VGND VGND VPWR VPWR sky130_fd_sc_hd__decap_3
XFILLER_100_188 VGND VGND VPWR VPWR sky130_fd_sc_hd__decap_3
XFILLER_27_412 VGND VGND VPWR VPWR sky130_fd_sc_hd__decap_3
XTAP_TAPCELL_ROW_68_1021 VGND VPWR sky130_fd_sc_hd__tapvpwrvgnd_1
XFILLER_54_242 VGND VGND VPWR VPWR sky130_fd_sc_hd__decap_3
XFILLER_54_253 VGND VGND VPWR VPWR sky130_fd_sc_hd__decap_3
XFILLER_14_106 VGND VGND VPWR VPWR sky130_fd_sc_hd__decap_3
XFILLER_15_629 VGND VGND VPWR VPWR sky130_fd_sc_hd__decap_3
XFILLER_54_297 VGND VGND VPWR VPWR sky130_fd_sc_hd__decap_3
XFILLER_14_139 VGND VGND VPWR VPWR sky130_fd_sc_hd__fill_1
X_6919_ clkload4/A _6919_/D VGND VGND VPWR VPWR _6919_/Q sky130_fd_sc_hd__dfxtp_2
XFILLER_52_57 VGND VGND VPWR VPWR sky130_fd_sc_hd__fill_1
XFILLER_10_312 VGND VGND VPWR VPWR sky130_fd_sc_hd__decap_3
XFILLER_10_334 VGND VGND VPWR VPWR sky130_fd_sc_hd__decap_3
XFILLER_22_183 VGND VGND VPWR VPWR sky130_fd_sc_hd__decap_3
XFILLER_50_492 VGND VGND VPWR VPWR sky130_fd_sc_hd__decap_3
XFILLER_108_222 VGND VGND VPWR VPWR sky130_fd_sc_hd__fill_2
XFILLER_108_299 VGND VGND VPWR VPWR sky130_fd_sc_hd__fill_1
XFILLER_2_533 VGND VGND VPWR VPWR sky130_fd_sc_hd__decap_3
XFILLER_2_566 VGND VGND VPWR VPWR sky130_fd_sc_hd__decap_3
XFILLER_104_472 VGND VGND VPWR VPWR sky130_fd_sc_hd__fill_1
XFILLER_89_150 VGND VGND VPWR VPWR sky130_fd_sc_hd__decap_3
XFILLER_104_494 VGND VGND VPWR VPWR sky130_fd_sc_hd__decap_3
XFILLER_77_334 VGND VGND VPWR VPWR sky130_fd_sc_hd__fill_2
XFILLER_77_378 VGND VGND VPWR VPWR sky130_fd_sc_hd__fill_1
XFILLER_77_389 VGND VGND VPWR VPWR sky130_fd_sc_hd__decap_3
XFILLER_92_315 VGND VGND VPWR VPWR sky130_fd_sc_hd__decap_3
XFILLER_92_326 VGND VGND VPWR VPWR sky130_fd_sc_hd__fill_1
XFILLER_18_445 VGND VGND VPWR VPWR sky130_fd_sc_hd__fill_1
XFILLER_18_467 VGND VGND VPWR VPWR sky130_fd_sc_hd__decap_3
XFILLER_45_231 VGND VGND VPWR VPWR sky130_fd_sc_hd__fill_1
Xhold1090 _7253_/Q VGND VGND VPWR VPWR _5126_/A0 sky130_fd_sc_hd__dlygate4sd3_1
XFILLER_14_640 VGND VGND VPWR VPWR sky130_fd_sc_hd__decap_3
XFILLER_60_256 VGND VGND VPWR VPWR sky130_fd_sc_hd__decap_3
XFILLER_13_172 VGND VGND VPWR VPWR sky130_fd_sc_hd__decap_3
XFILLER_41_481 VGND VGND VPWR VPWR sky130_fd_sc_hd__decap_3
XFILLER_9_143 VGND VGND VPWR VPWR sky130_fd_sc_hd__decap_3
X_3580_ _7033_/Q _3488_/B _4285_/B1 _7380_/Q VGND VGND VPWR VPWR _3580_/X sky130_fd_sc_hd__a22o_2
XTAP_TAPCELL_ROW_11_362 VGND VPWR sky130_fd_sc_hd__tapvpwrvgnd_1
XFILLER_9_187 VGND VGND VPWR VPWR sky130_fd_sc_hd__decap_3
XFILLER_5_382 VGND VGND VPWR VPWR sky130_fd_sc_hd__fill_2
XFILLER_47_3 VGND VGND VPWR VPWR sky130_fd_sc_hd__fill_2
XFILLER_5_393 VGND VGND VPWR VPWR sky130_fd_sc_hd__decap_3
X_4201_ _4186_/A _4636_/B _4200_/X VGND VGND VPWR VPWR _4201_/X sky130_fd_sc_hd__o21a_2
XFILLER_68_312 VGND VGND VPWR VPWR sky130_fd_sc_hd__decap_3
XFILLER_68_334 VGND VGND VPWR VPWR sky130_fd_sc_hd__decap_3
X_4132_ _7075_/Q _4265_/B _4432_/B1 _4131_/X VGND VGND VPWR VPWR _4207_/A sky130_fd_sc_hd__o211ai_2
XFILLER_3_84 VGND VGND VPWR VPWR sky130_fd_sc_hd__fill_1
XFILLER_56_518 VGND VGND VPWR VPWR sky130_fd_sc_hd__decap_3
XFILLER_95_142 VGND VGND VPWR VPWR sky130_fd_sc_hd__decap_3
X_4063_ _7116_/Q _4434_/A2 _4434_/B1 _7148_/Q VGND VGND VPWR VPWR _4063_/X sky130_fd_sc_hd__a22o_2
XFILLER_36_253 VGND VGND VPWR VPWR sky130_fd_sc_hd__decap_3
XTAP_TAPCELL_ROW_47_771 VGND VPWR sky130_fd_sc_hd__tapvpwrvgnd_1
XTAP_TAPCELL_ROW_19_451 VGND VPWR sky130_fd_sc_hd__tapvpwrvgnd_1
XFILLER_51_223 VGND VGND VPWR VPWR sky130_fd_sc_hd__fill_1
X_4965_ _4965_/A0 _4964_/X _4998_/S VGND VGND VPWR VPWR _7264_/D sky130_fd_sc_hd__mux2_2
XFILLER_51_267 VGND VGND VPWR VPWR sky130_fd_sc_hd__decap_3
X_6704_ _7361_/CLK _6704_/D VGND VGND VPWR VPWR _6704_/Q sky130_fd_sc_hd__dfxtp_2
XFILLER_20_610 VGND VGND VPWR VPWR sky130_fd_sc_hd__decap_3
XFILLER_20_643 VGND VGND VPWR VPWR sky130_fd_sc_hd__fill_1
X_4896_ _4896_/A _4896_/B VGND VGND VPWR VPWR _4896_/Y sky130_fd_sc_hd__nand2_2
XFILLER_22_38 VGND VGND VPWR VPWR sky130_fd_sc_hd__fill_1
X_6635_ _6635_/A VGND VGND VPWR VPWR _6635_/Y sky130_fd_sc_hd__inv_2
X_3847_ _6946_/Q _3887_/A2 _3887_/B1 _6958_/Q _3846_/X VGND VGND VPWR VPWR _3847_/X
+ sky130_fd_sc_hd__a221o_2
X_6566_ _6566_/A VGND VGND VPWR VPWR _6566_/Y sky130_fd_sc_hd__inv_2
X_3778_ _6930_/Q _3886_/A2 _3887_/B1 _6882_/Q VGND VGND VPWR VPWR _3778_/X sky130_fd_sc_hd__a22o_2
XFILLER_105_203 VGND VGND VPWR VPWR sky130_fd_sc_hd__decap_3
XFILLER_105_225 VGND VGND VPWR VPWR sky130_fd_sc_hd__decap_3
XFILLER_3_319 VGND VGND VPWR VPWR sky130_fd_sc_hd__fill_2
X_6497_ _6635_/A VGND VGND VPWR VPWR _6497_/Y sky130_fd_sc_hd__inv_2
Xoutput462 _5023_/Y VGND VGND VPWR VPWR alu_result_out[13] sky130_fd_sc_hd__clkdlybuf4s25_1
XFILLER_59_312 VGND VGND VPWR VPWR sky130_fd_sc_hd__decap_3
Xoutput495 _3429_/A VGND VGND VPWR VPWR instruction_out[15] sky130_fd_sc_hd__clkdlybuf4s25_1
Xoutput484 _3735_/A VGND VGND VPWR VPWR alu_result_out[4] sky130_fd_sc_hd__clkdlybuf4s25_1
Xoutput473 _5655_/D VGND VGND VPWR VPWR alu_result_out[23] sky130_fd_sc_hd__clkdlybuf4s25_1
X_5379_ _5379_/A0 _4836_/X _5392_/S VGND VGND VPWR VPWR _7143_/D sky130_fd_sc_hd__mux2_2
XTAP_TAPCELL_ROW_74_1091 VGND VPWR sky130_fd_sc_hd__tapvpwrvgnd_1
XTAP_TAPCELL_ROW_74_1080 VGND VPWR sky130_fd_sc_hd__tapvpwrvgnd_1
XFILLER_99_481 VGND VGND VPWR VPWR sky130_fd_sc_hd__decap_3
XFILLER_101_431 VGND VGND VPWR VPWR sky130_fd_sc_hd__decap_3
XFILLER_59_334 VGND VGND VPWR VPWR sky130_fd_sc_hd__fill_2
XFILLER_59_345 VGND VGND VPWR VPWR sky130_fd_sc_hd__decap_3
XFILLER_86_131 VGND VGND VPWR VPWR sky130_fd_sc_hd__decap_3
XFILLER_87_632 VGND VGND VPWR VPWR sky130_fd_sc_hd__decap_3
X_7118_ _7374_/CLK _7118_/D _6398_/Y VGND VGND VPWR VPWR _7118_/Q sky130_fd_sc_hd__dfrtp_2
XFILLER_101_464 VGND VGND VPWR VPWR sky130_fd_sc_hd__decap_3
XFILLER_59_356 VGND VGND VPWR VPWR sky130_fd_sc_hd__decap_3
XFILLER_59_389 VGND VGND VPWR VPWR sky130_fd_sc_hd__decap_3
X_7049_ _7392_/CLK _7049_/D _6329_/Y VGND VGND VPWR VPWR _7049_/Q sky130_fd_sc_hd__dfrtp_2
XFILLER_47_57 VGND VGND VPWR VPWR sky130_fd_sc_hd__fill_1
XPHY_EDGE_ROW_29_Right_29 VGND VGND VPWR VPWR sky130_fd_sc_hd__decap_3
XFILLER_103_30 VGND VGND VPWR VPWR sky130_fd_sc_hd__decap_3
XFILLER_27_253 VGND VGND VPWR VPWR sky130_fd_sc_hd__decap_3
XFILLER_103_52 VGND VGND VPWR VPWR sky130_fd_sc_hd__decap_3
XFILLER_42_212 VGND VGND VPWR VPWR sky130_fd_sc_hd__decap_3
XFILLER_63_23 VGND VGND VPWR VPWR sky130_fd_sc_hd__decap_3
XFILLER_70_521 VGND VGND VPWR VPWR sky130_fd_sc_hd__fill_2
XFILLER_63_45 VGND VGND VPWR VPWR sky130_fd_sc_hd__decap_3
XFILLER_82_392 VGND VGND VPWR VPWR sky130_fd_sc_hd__decap_3
XFILLER_42_267 VGND VGND VPWR VPWR sky130_fd_sc_hd__decap_3
XFILLER_70_587 VGND VGND VPWR VPWR sky130_fd_sc_hd__fill_1
XFILLER_11_632 VGND VGND VPWR VPWR sky130_fd_sc_hd__decap_3
XFILLER_70_598 VGND VGND VPWR VPWR sky130_fd_sc_hd__decap_3
XFILLER_8_29 VGND VGND VPWR VPWR sky130_fd_sc_hd__fill_1
XFILLER_10_131 VGND VGND VPWR VPWR sky130_fd_sc_hd__fill_2
XFILLER_7_603 VGND VGND VPWR VPWR sky130_fd_sc_hd__decap_3
XPHY_EDGE_ROW_38_Right_38 VGND VGND VPWR VPWR sky130_fd_sc_hd__decap_3
XFILLER_7_647 VGND VGND VPWR VPWR sky130_fd_sc_hd__fill_1
XFILLER_10_197 VGND VGND VPWR VPWR sky130_fd_sc_hd__decap_3
XFILLER_6_157 VGND VGND VPWR VPWR sky130_fd_sc_hd__decap_3
XFILLER_2_352 VGND VGND VPWR VPWR sky130_fd_sc_hd__decap_3
XFILLER_104_291 VGND VGND VPWR VPWR sky130_fd_sc_hd__decap_3
XFILLER_77_131 VGND VGND VPWR VPWR sky130_fd_sc_hd__decap_3
XFILLER_78_632 VGND VGND VPWR VPWR sky130_fd_sc_hd__decap_3
XFILLER_38_507 VGND VGND VPWR VPWR sky130_fd_sc_hd__decap_3
XFILLER_77_164 VGND VGND VPWR VPWR sky130_fd_sc_hd__decap_3
XFILLER_93_613 VGND VGND VPWR VPWR sky130_fd_sc_hd__decap_3
XPHY_EDGE_ROW_47_Right_47 VGND VGND VPWR VPWR sky130_fd_sc_hd__decap_3
XFILLER_65_337 VGND VGND VPWR VPWR sky130_fd_sc_hd__decap_3
XFILLER_77_175 VGND VGND VPWR VPWR sky130_fd_sc_hd__decap_3
XFILLER_93_635 VGND VGND VPWR VPWR sky130_fd_sc_hd__decap_3
XTAP_TAPCELL_ROW_88_1249 VGND VPWR sky130_fd_sc_hd__tapvpwrvgnd_1
XFILLER_92_134 VGND VGND VPWR VPWR sky130_fd_sc_hd__decap_3
XFILLER_92_156 VGND VGND VPWR VPWR sky130_fd_sc_hd__decap_3
XFILLER_18_253 VGND VGND VPWR VPWR sky130_fd_sc_hd__fill_2
XFILLER_46_595 VGND VGND VPWR VPWR sky130_fd_sc_hd__fill_1
XFILLER_73_370 VGND VGND VPWR VPWR sky130_fd_sc_hd__decap_3
XFILLER_80_318 VGND VGND VPWR VPWR sky130_fd_sc_hd__fill_2
XFILLER_33_234 VGND VGND VPWR VPWR sky130_fd_sc_hd__fill_1
XFILLER_61_532 VGND VGND VPWR VPWR sky130_fd_sc_hd__decap_3
XTAP_TAPCELL_ROW_44_741 VGND VPWR sky130_fd_sc_hd__tapvpwrvgnd_1
XTAP_TAPCELL_ROW_16_421 VGND VPWR sky130_fd_sc_hd__tapvpwrvgnd_1
XFILLER_21_407 VGND VGND VPWR VPWR sky130_fd_sc_hd__decap_3
XFILLER_33_267 VGND VGND VPWR VPWR sky130_fd_sc_hd__decap_3
X_4750_ _4909_/A _4750_/B _4750_/C VGND VGND VPWR VPWR _4751_/B sky130_fd_sc_hd__or3_2
XPHY_EDGE_ROW_56_Right_56 VGND VGND VPWR VPWR sky130_fd_sc_hd__decap_3
X_4681_ _4982_/B _5009_/A _6992_/Q _6993_/Q _6994_/Q VGND VGND VPWR VPWR _4960_/B
+ sky130_fd_sc_hd__o2111a_2
X_3701_ _3682_/A _3700_/X _5104_/A VGND VGND VPWR VPWR _3701_/X sky130_fd_sc_hd__a21o_2
X_6420_ _6645_/A VGND VGND VPWR VPWR _6420_/Y sky130_fd_sc_hd__inv_2
X_3632_ _3630_/A _3501_/X _3502_/X _3505_/B _5020_/A VGND VGND VPWR VPWR _3632_/X
+ sky130_fd_sc_hd__a311o_2
XTAP_TAPCELL_ROW_99_1378 VGND VPWR sky130_fd_sc_hd__tapvpwrvgnd_1
X_6351_ _6677_/A VGND VGND VPWR VPWR _6351_/Y sky130_fd_sc_hd__inv_2
XFILLER_108_19 VGND VGND VPWR VPWR sky130_fd_sc_hd__fill_1
X_5302_ _5302_/A0 _4771_/X _5310_/S VGND VGND VPWR VPWR _7179_/D sky130_fd_sc_hd__mux2_2
X_6282_ _6397_/A VGND VGND VPWR VPWR _6282_/Y sky130_fd_sc_hd__inv_2
X_3494_ _7183_/Q _4471_/S _3380_/Y _7375_/Q VGND VGND VPWR VPWR _3494_/X sky130_fd_sc_hd__a22o_2
XPHY_EDGE_ROW_65_Right_65 VGND VGND VPWR VPWR sky130_fd_sc_hd__decap_3
XFILLER_69_632 VGND VGND VPWR VPWR sky130_fd_sc_hd__decap_3
X_4115_ _7268_/Q _4190_/A2 _4349_/B1 _7236_/Q _4114_/X VGND VGND VPWR VPWR _4117_/B
+ sky130_fd_sc_hd__a221o_2
XFILLER_56_315 VGND VGND VPWR VPWR sky130_fd_sc_hd__decap_3
XFILLER_68_197 VGND VGND VPWR VPWR sky130_fd_sc_hd__decap_3
X_5095_ _5095_/A0 _5094_/X _5159_/S VGND VGND VPWR VPWR _7256_/D sky130_fd_sc_hd__mux2_2
XPHY_EDGE_ROW_3_Left_112 VGND VGND VPWR VPWR sky130_fd_sc_hd__decap_3
XFILLER_83_134 VGND VGND VPWR VPWR sky130_fd_sc_hd__decap_3
X_4046_ _7373_/Q _4270_/B _4416_/B1 _7181_/Q VGND VGND VPWR VPWR _4046_/X sky130_fd_sc_hd__a22o_2
XFILLER_17_49 VGND VGND VPWR VPWR sky130_fd_sc_hd__fill_1
XFILLER_37_573 VGND VGND VPWR VPWR sky130_fd_sc_hd__decap_3
XFILLER_83_178 VGND VGND VPWR VPWR sky130_fd_sc_hd__decap_3
XTAP_TAPCELL_ROW_108_1474 VGND VPWR sky130_fd_sc_hd__tapvpwrvgnd_1
XFILLER_24_212 VGND VGND VPWR VPWR sky130_fd_sc_hd__decap_3
XFILLER_37_595 VGND VGND VPWR VPWR sky130_fd_sc_hd__decap_3
XFILLER_64_392 VGND VGND VPWR VPWR sky130_fd_sc_hd__decap_3
XTAP_TAPCELL_ROW_108_1485 VGND VPWR sky130_fd_sc_hd__tapvpwrvgnd_1
XFILLER_24_256 VGND VGND VPWR VPWR sky130_fd_sc_hd__decap_3
XPHY_EDGE_ROW_74_Right_74 VGND VGND VPWR VPWR sky130_fd_sc_hd__decap_3
XFILLER_12_429 VGND VGND VPWR VPWR sky130_fd_sc_hd__decap_3
XFILLER_24_289 VGND VGND VPWR VPWR sky130_fd_sc_hd__decap_3
X_4948_ _4948_/A _4948_/B VGND VGND VPWR VPWR _4948_/Y sky130_fd_sc_hd__nor2_2
X_4879_ _4879_/A0 _4878_/X _4946_/S VGND VGND VPWR VPWR _7269_/D sky130_fd_sc_hd__mux2_2
X_6618_ _6618_/A VGND VGND VPWR VPWR _6618_/Y sky130_fd_sc_hd__inv_2
XPHY_EDGE_ROW_49_Left_158 VGND VGND VPWR VPWR sky130_fd_sc_hd__decap_3
XFILLER_4_628 VGND VGND VPWR VPWR sky130_fd_sc_hd__decap_3
X_6549_ _6552_/A VGND VGND VPWR VPWR _6549_/Y sky130_fd_sc_hd__inv_2
XFILLER_3_149 VGND VGND VPWR VPWR sky130_fd_sc_hd__decap_3
XPHY_EDGE_ROW_83_Right_83 VGND VGND VPWR VPWR sky130_fd_sc_hd__decap_3
XFILLER_106_578 VGND VGND VPWR VPWR sky130_fd_sc_hd__decap_3
XFILLER_106_589 VGND VGND VPWR VPWR sky130_fd_sc_hd__fill_1
XFILLER_58_45 VGND VGND VPWR VPWR sky130_fd_sc_hd__fill_2
XFILLER_58_56 VGND VGND VPWR VPWR sky130_fd_sc_hd__decap_3
XFILLER_59_142 VGND VGND VPWR VPWR sky130_fd_sc_hd__fill_1
XFILLER_59_153 VGND VGND VPWR VPWR sky130_fd_sc_hd__decap_3
XFILLER_75_613 VGND VGND VPWR VPWR sky130_fd_sc_hd__decap_3
XFILLER_87_440 VGND VGND VPWR VPWR sky130_fd_sc_hd__decap_3
XPHY_EDGE_ROW_58_Left_167 VGND VGND VPWR VPWR sky130_fd_sc_hd__decap_3
XFILLER_101_272 VGND VGND VPWR VPWR sky130_fd_sc_hd__decap_3
XFILLER_47_337 VGND VGND VPWR VPWR sky130_fd_sc_hd__fill_1
XFILLER_59_175 VGND VGND VPWR VPWR sky130_fd_sc_hd__decap_3
XFILLER_59_197 VGND VGND VPWR VPWR sky130_fd_sc_hd__decap_3
XFILLER_74_156 VGND VGND VPWR VPWR sky130_fd_sc_hd__decap_3
XTAP_TAPCELL_ROW_58_899 VGND VPWR sky130_fd_sc_hd__tapvpwrvgnd_1
XFILLER_15_223 VGND VGND VPWR VPWR sky130_fd_sc_hd__fill_1
XFILLER_28_595 VGND VGND VPWR VPWR sky130_fd_sc_hd__decap_3
XPHY_EDGE_ROW_92_Right_92 VGND VGND VPWR VPWR sky130_fd_sc_hd__decap_3
XFILLER_15_278 VGND VGND VPWR VPWR sky130_fd_sc_hd__fill_2
XFILLER_43_576 VGND VGND VPWR VPWR sky130_fd_sc_hd__fill_1
XFILLER_70_340 VGND VGND VPWR VPWR sky130_fd_sc_hd__decap_3
XFILLER_30_215 VGND VGND VPWR VPWR sky130_fd_sc_hd__decap_3
XFILLER_70_395 VGND VGND VPWR VPWR sky130_fd_sc_hd__decap_3
XFILLER_90_32 VGND VGND VPWR VPWR sky130_fd_sc_hd__fill_2
XTAP_TAPCELL_ROW_41_711 VGND VPWR sky130_fd_sc_hd__tapvpwrvgnd_1
XPHY_EDGE_ROW_67_Left_176 VGND VGND VPWR VPWR sky130_fd_sc_hd__decap_3
XFILLER_30_248 VGND VGND VPWR VPWR sky130_fd_sc_hd__fill_1
XFILLER_30_259 VGND VGND VPWR VPWR sky130_fd_sc_hd__decap_3
XFILLER_11_473 VGND VGND VPWR VPWR sky130_fd_sc_hd__decap_3
XFILLER_7_411 VGND VGND VPWR VPWR sky130_fd_sc_hd__fill_1
XFILLER_99_74 VGND VGND VPWR VPWR sky130_fd_sc_hd__fill_1
XFILLER_2_171 VGND VGND VPWR VPWR sky130_fd_sc_hd__decap_3
XFILLER_31_6 VGND VGND VPWR VPWR sky130_fd_sc_hd__fill_2
XPHY_EDGE_ROW_76_Left_185 VGND VGND VPWR VPWR sky130_fd_sc_hd__decap_3
XFILLER_97_237 VGND VGND VPWR VPWR sky130_fd_sc_hd__decap_3
XFILLER_66_613 VGND VGND VPWR VPWR sky130_fd_sc_hd__decap_3
XTAP_TAPCELL_ROW_49_800 VGND VPWR sky130_fd_sc_hd__tapvpwrvgnd_1
XFILLER_38_315 VGND VGND VPWR VPWR sky130_fd_sc_hd__decap_3
XFILLER_19_551 VGND VGND VPWR VPWR sky130_fd_sc_hd__decap_3
XFILLER_65_145 VGND VGND VPWR VPWR sky130_fd_sc_hd__decap_3
XFILLER_80_115 VGND VGND VPWR VPWR sky130_fd_sc_hd__decap_3
XFILLER_81_638 VGND VGND VPWR VPWR sky130_fd_sc_hd__decap_3
XFILLER_80_137 VGND VGND VPWR VPWR sky130_fd_sc_hd__decap_3
XPHY_EDGE_ROW_85_Left_194 VGND VGND VPWR VPWR sky130_fd_sc_hd__decap_3
XFILLER_21_204 VGND VGND VPWR VPWR sky130_fd_sc_hd__decap_3
XFILLER_61_373 VGND VGND VPWR VPWR sky130_fd_sc_hd__fill_1
X_4802_ _7002_/Q _5622_/B _4834_/A VGND VGND VPWR VPWR _4802_/X sky130_fd_sc_hd__o21a_2
XPHY_EDGE_ROW_100_Right_100 VGND VGND VPWR VPWR sky130_fd_sc_hd__decap_3
XFILLER_9_50 VGND VGND VPWR VPWR sky130_fd_sc_hd__decap_3
X_6403_ _6628_/A VGND VGND VPWR VPWR _6403_/Y sky130_fd_sc_hd__inv_2
X_4664_ _4983_/A _4664_/B _5665_/A VGND VGND VPWR VPWR _4664_/X sky130_fd_sc_hd__or3b_4
X_7383_ _7383_/CLK _7383_/D _6663_/Y VGND VGND VPWR VPWR _7383_/Q sky130_fd_sc_hd__dfrtp_2
Xhold901 _7095_/Q VGND VGND VPWR VPWR _7095_/D sky130_fd_sc_hd__dlygate4sd3_1
Xhold912 _6713_/Q VGND VGND VPWR VPWR hold912/X sky130_fd_sc_hd__dlygate4sd3_1
X_4595_ _4595_/A _4595_/B VGND VGND VPWR VPWR _7283_/D sky130_fd_sc_hd__and2_2
X_3615_ _3508_/A _3547_/Y _3427_/B VGND VGND VPWR VPWR _3616_/B sky130_fd_sc_hd__o21ai_2
Xhold923 _7031_/Q VGND VGND VPWR VPWR _5593_/A sky130_fd_sc_hd__dlygate4sd3_1
Xhold934 _7025_/Q VGND VGND VPWR VPWR _5605_/A sky130_fd_sc_hd__dlygate4sd3_1
Xhold945 _7036_/Q VGND VGND VPWR VPWR hold945/X sky130_fd_sc_hd__dlygate4sd3_1
X_6334_ _6650_/A VGND VGND VPWR VPWR _6334_/Y sky130_fd_sc_hd__inv_2
X_3546_ _3630_/A _3630_/B _3635_/A _3636_/A VGND VGND VPWR VPWR _3547_/B sky130_fd_sc_hd__a211o_2
Xhold989 _7239_/Q VGND VGND VPWR VPWR _5177_/A sky130_fd_sc_hd__dlygate4sd3_1
Xhold978 _7383_/Q VGND VGND VPWR VPWR hold978/X sky130_fd_sc_hd__dlygate4sd3_1
Xhold967 _7035_/Q VGND VGND VPWR VPWR hold967/X sky130_fd_sc_hd__dlygate4sd3_1
Xhold956 _7382_/Q VGND VGND VPWR VPWR hold956/X sky130_fd_sc_hd__dlygate4sd3_1
X_6265_ _6668_/A VGND VGND VPWR VPWR _6265_/Y sky130_fd_sc_hd__inv_2
XFILLER_103_548 VGND VGND VPWR VPWR sky130_fd_sc_hd__decap_3
XFILLER_88_226 VGND VGND VPWR VPWR sky130_fd_sc_hd__decap_3
X_3477_ _7184_/Q _4471_/S _3380_/Y _7376_/Q VGND VGND VPWR VPWR _3477_/X sky130_fd_sc_hd__a22o_2
XTAP_TAPCELL_ROW_71_1050 VGND VPWR sky130_fd_sc_hd__tapvpwrvgnd_1
XFILLER_28_37 VGND VGND VPWR VPWR sky130_fd_sc_hd__fill_1
XFILLER_29_326 VGND VGND VPWR VPWR sky130_fd_sc_hd__decap_3
XFILLER_29_337 VGND VGND VPWR VPWR sky130_fd_sc_hd__decap_3
XFILLER_57_635 VGND VGND VPWR VPWR sky130_fd_sc_hd__decap_3
XFILLER_84_421 VGND VGND VPWR VPWR sky130_fd_sc_hd__decap_3
X_5147_ _5145_/A _3541_/X _5146_/Y VGND VGND VPWR VPWR _5147_/X sky130_fd_sc_hd__a21o_2
XFILLER_96_281 VGND VGND VPWR VPWR sky130_fd_sc_hd__decap_3
XFILLER_56_123 VGND VGND VPWR VPWR sky130_fd_sc_hd__decap_3
X_5078_ _4467_/Y _5069_/X _5077_/X _4467_/B _5666_/A VGND VGND VPWR VPWR _5078_/X
+ sky130_fd_sc_hd__a221o_2
XFILLER_44_307 VGND VGND VPWR VPWR sky130_fd_sc_hd__fill_1
XFILLER_84_498 VGND VGND VPWR VPWR sky130_fd_sc_hd__decap_3
XFILLER_71_137 VGND VGND VPWR VPWR sky130_fd_sc_hd__decap_3
XTAP_TAPCELL_ROW_55_869 VGND VPWR sky130_fd_sc_hd__tapvpwrvgnd_1
XTAP_TAPCELL_ROW_27_549 VGND VPWR sky130_fd_sc_hd__tapvpwrvgnd_1
XFILLER_44_58 VGND VGND VPWR VPWR sky130_fd_sc_hd__decap_3
XFILLER_100_20 VGND VGND VPWR VPWR sky130_fd_sc_hd__decap_3
XFILLER_12_215 VGND VGND VPWR VPWR sky130_fd_sc_hd__decap_3
XFILLER_12_248 VGND VGND VPWR VPWR sky130_fd_sc_hd__decap_3
XFILLER_12_259 VGND VGND VPWR VPWR sky130_fd_sc_hd__decap_3
XFILLER_60_57 VGND VGND VPWR VPWR sky130_fd_sc_hd__decap_3
XFILLER_60_79 VGND VGND VPWR VPWR sky130_fd_sc_hd__decap_3
XFILLER_4_458 VGND VGND VPWR VPWR sky130_fd_sc_hd__decap_3
XFILLER_0_620 VGND VGND VPWR VPWR sky130_fd_sc_hd__fill_1
XFILLER_106_386 VGND VGND VPWR VPWR sky130_fd_sc_hd__fill_1
XFILLER_79_259 VGND VGND VPWR VPWR sky130_fd_sc_hd__decap_3
XFILLER_48_613 VGND VGND VPWR VPWR sky130_fd_sc_hd__decap_3
XFILLER_85_32 VGND VGND VPWR VPWR sky130_fd_sc_hd__decap_3
XFILLER_87_270 VGND VGND VPWR VPWR sky130_fd_sc_hd__fill_1
XFILLER_47_134 VGND VGND VPWR VPWR sky130_fd_sc_hd__decap_3
XFILLER_75_432 VGND VGND VPWR VPWR sky130_fd_sc_hd__decap_3
XFILLER_85_76 VGND VGND VPWR VPWR sky130_fd_sc_hd__fill_2
XFILLER_47_167 VGND VGND VPWR VPWR sky130_fd_sc_hd__fill_1
XFILLER_47_189 VGND VGND VPWR VPWR sky130_fd_sc_hd__decap_3
XFILLER_62_104 VGND VGND VPWR VPWR sky130_fd_sc_hd__decap_3
XFILLER_63_638 VGND VGND VPWR VPWR sky130_fd_sc_hd__decap_3
XFILLER_75_498 VGND VGND VPWR VPWR sky130_fd_sc_hd__decap_3
XFILLER_85_98 VGND VGND VPWR VPWR sky130_fd_sc_hd__fill_2
XFILLER_90_402 VGND VGND VPWR VPWR sky130_fd_sc_hd__decap_3
XTAP_TAPCELL_ROW_85_1208 VGND VPWR sky130_fd_sc_hd__tapvpwrvgnd_1
XFILLER_16_510 VGND VGND VPWR VPWR sky130_fd_sc_hd__decap_3
XFILLER_90_435 VGND VGND VPWR VPWR sky130_fd_sc_hd__decap_3
XFILLER_43_351 VGND VGND VPWR VPWR sky130_fd_sc_hd__fill_2
XFILLER_90_468 VGND VGND VPWR VPWR sky130_fd_sc_hd__decap_3
XFILLER_16_598 VGND VGND VPWR VPWR sky130_fd_sc_hd__decap_3
XFILLER_70_181 VGND VGND VPWR VPWR sky130_fd_sc_hd__decap_3
XFILLER_31_557 VGND VGND VPWR VPWR sky130_fd_sc_hd__decap_3
XFILLER_34_91 VGND VGND VPWR VPWR sky130_fd_sc_hd__decap_3
XFILLER_11_281 VGND VGND VPWR VPWR sky130_fd_sc_hd__decap_3
XFILLER_7_252 VGND VGND VPWR VPWR sky130_fd_sc_hd__decap_3
XTAP_TAPCELL_ROW_96_1337 VGND VPWR sky130_fd_sc_hd__tapvpwrvgnd_1
X_4380_ _4380_/A _4380_/B VGND VGND VPWR VPWR _4381_/B sky130_fd_sc_hd__or2_2
X_3400_ _3449_/B VGND VGND VPWR VPWR _3421_/B sky130_fd_sc_hd__inv_2
X_3331_ _3365_/A _3353_/B _5135_/A1 VGND VGND VPWR VPWR _3528_/A sky130_fd_sc_hd__or3b_2
XFILLER_39_635 VGND VGND VPWR VPWR sky130_fd_sc_hd__decap_3
XFILLER_66_410 VGND VGND VPWR VPWR sky130_fd_sc_hd__fill_1
X_5001_ _5001_/A _5001_/B VGND VGND VPWR VPWR _6991_/D sky130_fd_sc_hd__nor2_2
XFILLER_26_318 VGND VGND VPWR VPWR sky130_fd_sc_hd__decap_3
XFILLER_26_329 VGND VGND VPWR VPWR sky130_fd_sc_hd__decap_3
XFILLER_38_167 VGND VGND VPWR VPWR sky130_fd_sc_hd__fill_1
XFILLER_54_605 VGND VGND VPWR VPWR sky130_fd_sc_hd__decap_3
XFILLER_54_638 VGND VGND VPWR VPWR sky130_fd_sc_hd__decap_3
XFILLER_66_465 VGND VGND VPWR VPWR sky130_fd_sc_hd__fill_2
XFILLER_93_262 VGND VGND VPWR VPWR sky130_fd_sc_hd__decap_3
XFILLER_19_370 VGND VGND VPWR VPWR sky130_fd_sc_hd__decap_3
XFILLER_81_424 VGND VGND VPWR VPWR sky130_fd_sc_hd__decap_3
XFILLER_93_284 VGND VGND VPWR VPWR sky130_fd_sc_hd__fill_2
X_6952_ _6958_/CLK _6952_/D VGND VGND VPWR VPWR _6952_/Q sky130_fd_sc_hd__dfxtp_2
XPHY_EDGE_ROW_93_Left_202 VGND VGND VPWR VPWR sky130_fd_sc_hd__decap_3
XFILLER_53_159 VGND VGND VPWR VPWR sky130_fd_sc_hd__decap_3
XFILLER_81_479 VGND VGND VPWR VPWR sky130_fd_sc_hd__decap_3
X_6883_ _7071_/CLK _6883_/D VGND VGND VPWR VPWR _6883_/Q sky130_fd_sc_hd__dfxtp_2
XTAP_TAPCELL_ROW_24_508 VGND VPWR sky130_fd_sc_hd__tapvpwrvgnd_1
XTAP_TAPCELL_ROW_105_1444 VGND VPWR sky130_fd_sc_hd__tapvpwrvgnd_1
XFILLER_34_362 VGND VGND VPWR VPWR sky130_fd_sc_hd__fill_2
XTAP_TAPCELL_ROW_52_828 VGND VPWR sky130_fd_sc_hd__tapvpwrvgnd_1
X_4716_ _5092_/C _4664_/X _4695_/X _7008_/D _4878_/A1 VGND VGND VPWR VPWR _4716_/X
+ sky130_fd_sc_hd__a32o_2
XFILLER_108_629 VGND VGND VPWR VPWR sky130_fd_sc_hd__decap_3
X_4647_ _4813_/A _4827_/A _4795_/A _4787_/A VGND VGND VPWR VPWR _4647_/X sky130_fd_sc_hd__and4_2
X_7366_ _7366_/CLK _7366_/D _6646_/Y VGND VGND VPWR VPWR _7366_/Q sky130_fd_sc_hd__dfrtp_2
Xhold720 _6721_/Q VGND VGND VPWR VPWR _6721_/D sky130_fd_sc_hd__dlygate4sd3_1
XFILLER_89_502 VGND VGND VPWR VPWR sky130_fd_sc_hd__fill_2
Xhold731 _6887_/Q VGND VGND VPWR VPWR _6887_/D sky130_fd_sc_hd__dlygate4sd3_1
Xhold742 _6839_/Q VGND VGND VPWR VPWR _6839_/D sky130_fd_sc_hd__dlygate4sd3_1
Xhold753 _6863_/Q VGND VGND VPWR VPWR _6863_/D sky130_fd_sc_hd__dlygate4sd3_1
Xhold764 _6852_/Q VGND VGND VPWR VPWR _6852_/D sky130_fd_sc_hd__dlygate4sd3_1
X_6317_ _6636_/A VGND VGND VPWR VPWR _6317_/Y sky130_fd_sc_hd__inv_2
XFILLER_1_439 VGND VGND VPWR VPWR sky130_fd_sc_hd__decap_3
X_7297_ _7366_/CLK _7297_/D _6577_/Y VGND VGND VPWR VPWR _7297_/Q sky130_fd_sc_hd__dfrtp_2
Xhold775 _6883_/Q VGND VGND VPWR VPWR _6883_/D sky130_fd_sc_hd__dlygate4sd3_1
Xhold786 _6764_/Q VGND VGND VPWR VPWR _6764_/D sky130_fd_sc_hd__dlygate4sd3_1
Xhold797 _6790_/Q VGND VGND VPWR VPWR _6790_/D sky130_fd_sc_hd__dlygate4sd3_1
XFILLER_103_367 VGND VGND VPWR VPWR sky130_fd_sc_hd__decap_3
XFILLER_39_47 VGND VGND VPWR VPWR sky130_fd_sc_hd__decap_3
XFILLER_103_389 VGND VGND VPWR VPWR sky130_fd_sc_hd__decap_3
XFILLER_39_69 VGND VGND VPWR VPWR sky130_fd_sc_hd__decap_3
XFILLER_69_270 VGND VGND VPWR VPWR sky130_fd_sc_hd__fill_2
XFILLER_76_218 VGND VGND VPWR VPWR sky130_fd_sc_hd__decap_3
XFILLER_69_281 VGND VGND VPWR VPWR sky130_fd_sc_hd__decap_3
XFILLER_17_307 VGND VGND VPWR VPWR sky130_fd_sc_hd__decap_3
XFILLER_17_318 VGND VGND VPWR VPWR sky130_fd_sc_hd__decap_3
XFILLER_29_178 VGND VGND VPWR VPWR sky130_fd_sc_hd__decap_3
XFILLER_57_465 VGND VGND VPWR VPWR sky130_fd_sc_hd__fill_2
XFILLER_84_262 VGND VGND VPWR VPWR sky130_fd_sc_hd__fill_2
XTAP_TAPCELL_ROW_4_277 VGND VPWR sky130_fd_sc_hd__tapvpwrvgnd_1
XFILLER_45_638 VGND VGND VPWR VPWR sky130_fd_sc_hd__decap_3
XFILLER_55_57 VGND VGND VPWR VPWR sky130_fd_sc_hd__decap_3
XFILLER_72_424 VGND VGND VPWR VPWR sky130_fd_sc_hd__decap_3
XFILLER_25_340 VGND VGND VPWR VPWR sky130_fd_sc_hd__fill_1
XFILLER_44_159 VGND VGND VPWR VPWR sky130_fd_sc_hd__decap_3
XFILLER_13_502 VGND VGND VPWR VPWR sky130_fd_sc_hd__fill_2
XFILLER_25_362 VGND VGND VPWR VPWR sky130_fd_sc_hd__decap_3
XFILLER_40_321 VGND VGND VPWR VPWR sky130_fd_sc_hd__decap_3
XFILLER_52_192 VGND VGND VPWR VPWR sky130_fd_sc_hd__decap_3
XTAP_TAPCELL_ROW_80_1149 VGND VPWR sky130_fd_sc_hd__tapvpwrvgnd_1
XFILLER_13_579 VGND VGND VPWR VPWR sky130_fd_sc_hd__decap_3
XFILLER_40_365 VGND VGND VPWR VPWR sky130_fd_sc_hd__decap_3
XFILLER_21_590 VGND VGND VPWR VPWR sky130_fd_sc_hd__decap_3
XFILLER_4_200 VGND VGND VPWR VPWR sky130_fd_sc_hd__fill_1
XFILLER_20_60 VGND VGND VPWR VPWR sky130_fd_sc_hd__decap_3
XFILLER_106_161 VGND VGND VPWR VPWR sky130_fd_sc_hd__decap_3
XFILLER_4_288 VGND VGND VPWR VPWR sky130_fd_sc_hd__decap_3
XTAP_TAPCELL_ROW_91_1278 VGND VPWR sky130_fd_sc_hd__tapvpwrvgnd_1
XFILLER_95_505 VGND VGND VPWR VPWR sky130_fd_sc_hd__decap_3
XFILLER_75_262 VGND VGND VPWR VPWR sky130_fd_sc_hd__decap_3
XFILLER_36_638 VGND VGND VPWR VPWR sky130_fd_sc_hd__decap_3
XFILLER_75_284 VGND VGND VPWR VPWR sky130_fd_sc_hd__fill_2
XFILLER_75_295 VGND VGND VPWR VPWR sky130_fd_sc_hd__decap_3
Xplace402 _4495_/S VGND VGND VPWR VPWR _4501_/S sky130_fd_sc_hd__buf_2
Xplace413 _4354_/B1 VGND VGND VPWR VPWR _4261_/A2 sky130_fd_sc_hd__buf_2
XFILLER_51_608 VGND VGND VPWR VPWR sky130_fd_sc_hd__decap_3
Xplace424 _3996_/S VGND VGND VPWR VPWR _3989_/S sky130_fd_sc_hd__buf_2
Xplace435 _4983_/A VGND VGND VPWR VPWR _4777_/A sky130_fd_sc_hd__buf_2
Xplace446 _5670_/A VGND VGND VPWR VPWR _4697_/A sky130_fd_sc_hd__buf_2
XFILLER_16_362 VGND VGND VPWR VPWR sky130_fd_sc_hd__fill_2
Xplace457 _6979_/Q VGND VGND VPWR VPWR _3353_/B sky130_fd_sc_hd__buf_2
XFILLER_31_343 VGND VGND VPWR VPWR sky130_fd_sc_hd__decap_3
X_3880_ _3714_/X _3877_/X _3879_/X _3735_/X VGND VGND VPWR VPWR _3880_/X sky130_fd_sc_hd__a22o_2
XFILLER_31_376 VGND VGND VPWR VPWR sky130_fd_sc_hd__decap_3
XTAP_TAPCELL_ROW_100_1385 VGND VPWR sky130_fd_sc_hd__tapvpwrvgnd_1
XFILLER_8_572 VGND VGND VPWR VPWR sky130_fd_sc_hd__decap_3
X_4501_ _4501_/A0 _7297_/Q _4501_/S VGND VGND VPWR VPWR _7329_/D sky130_fd_sc_hd__mux2_2
X_7220_ _7349_/CLK _7220_/D _6500_/Y VGND VGND VPWR VPWR _7220_/Q sky130_fd_sc_hd__dfrtp_2
X_4432_ _7079_/Q _4102_/B _4432_/B1 _4431_/X VGND VGND VPWR VPWR _4440_/A sky130_fd_sc_hd__o211ai_2
X_7151_ _7376_/CLK _7151_/D _6431_/Y VGND VGND VPWR VPWR _7151_/Q sky130_fd_sc_hd__dfrtp_2
X_4363_ _4619_/B VGND VGND VPWR VPWR _4369_/A sky130_fd_sc_hd__inv_2
X_7082_ _7083_/CLK _7082_/D _6362_/Y VGND VGND VPWR VPWR _7082_/Q sky130_fd_sc_hd__dfrtp_2
X_4294_ _4294_/A _4612_/B VGND VGND VPWR VPWR _5113_/A sky130_fd_sc_hd__xor2_2
X_3314_ _4467_/A _4467_/B VGND VGND VPWR VPWR _5647_/A sky130_fd_sc_hd__or2_2
XFILLER_98_365 VGND VGND VPWR VPWR sky130_fd_sc_hd__decap_3
XFILLER_100_315 VGND VGND VPWR VPWR sky130_fd_sc_hd__decap_3
XFILLER_100_337 VGND VGND VPWR VPWR sky130_fd_sc_hd__decap_3
XFILLER_94_560 VGND VGND VPWR VPWR sky130_fd_sc_hd__decap_3
XFILLER_26_126 VGND VGND VPWR VPWR sky130_fd_sc_hd__fill_2
XFILLER_26_137 VGND VGND VPWR VPWR sky130_fd_sc_hd__decap_3
XFILLER_27_638 VGND VGND VPWR VPWR sky130_fd_sc_hd__decap_3
XFILLER_39_498 VGND VGND VPWR VPWR sky130_fd_sc_hd__decap_3
XTAP_TAPCELL_ROW_1_247 VGND VPWR sky130_fd_sc_hd__tapvpwrvgnd_1
X_6935_ _6968_/CLK _6935_/D VGND VGND VPWR VPWR _6935_/Q sky130_fd_sc_hd__dfxtp_2
XTAP_TAPCELL_ROW_37_655 VGND VPWR sky130_fd_sc_hd__tapvpwrvgnd_1
XTAP_TAPCELL_ROW_65_986 VGND VPWR sky130_fd_sc_hd__tapvpwrvgnd_1
XFILLER_50_641 VGND VGND VPWR VPWR sky130_fd_sc_hd__decap_3
X_6866_ clkload4/A _6866_/D VGND VGND VPWR VPWR _6866_/Q sky130_fd_sc_hd__dfxtp_2
X_6797_ _6943_/CLK _6797_/D VGND VGND VPWR VPWR _6797_/Q sky130_fd_sc_hd__dfxtp_2
XFILLER_108_437 VGND VGND VPWR VPWR sky130_fd_sc_hd__decap_3
XFILLER_104_632 VGND VGND VPWR VPWR sky130_fd_sc_hd__decap_3
XFILLER_1_203 VGND VGND VPWR VPWR sky130_fd_sc_hd__decap_3
XFILLER_1_225 VGND VGND VPWR VPWR sky130_fd_sc_hd__decap_3
XFILLER_89_332 VGND VGND VPWR VPWR sky130_fd_sc_hd__decap_3
X_7349_ _7349_/CLK _7349_/D _6629_/Y VGND VGND VPWR VPWR _7349_/Q sky130_fd_sc_hd__dfrtp_2
XTAP_TAPCELL_ROW_9_336 VGND VPWR sky130_fd_sc_hd__tapvpwrvgnd_1
XFILLER_1_258 VGND VGND VPWR VPWR sky130_fd_sc_hd__decap_3
Xhold583 _6944_/Q VGND VGND VPWR VPWR _6944_/D sky130_fd_sc_hd__dlygate4sd3_1
Xhold594 _6810_/Q VGND VGND VPWR VPWR _6810_/D sky130_fd_sc_hd__dlygate4sd3_1
XFILLER_103_175 VGND VGND VPWR VPWR sky130_fd_sc_hd__decap_3
XFILLER_106_41 VGND VGND VPWR VPWR sky130_fd_sc_hd__decap_3
XFILLER_49_218 VGND VGND VPWR VPWR sky130_fd_sc_hd__decap_3
XFILLER_77_527 VGND VGND VPWR VPWR sky130_fd_sc_hd__decap_3
XFILLER_103_197 VGND VGND VPWR VPWR sky130_fd_sc_hd__decap_3
XFILLER_106_74 VGND VGND VPWR VPWR sky130_fd_sc_hd__fill_2
XFILLER_106_85 VGND VGND VPWR VPWR sky130_fd_sc_hd__decap_3
XFILLER_18_616 VGND VGND VPWR VPWR sky130_fd_sc_hd__decap_3
XFILLER_72_221 VGND VGND VPWR VPWR sky130_fd_sc_hd__decap_3
XFILLER_17_159 VGND VGND VPWR VPWR sky130_fd_sc_hd__decap_3
XFILLER_32_129 VGND VGND VPWR VPWR sky130_fd_sc_hd__decap_3
XFILLER_60_416 VGND VGND VPWR VPWR sky130_fd_sc_hd__decap_3
XFILLER_60_427 VGND VGND VPWR VPWR sky130_fd_sc_hd__fill_1
XFILLER_72_287 VGND VGND VPWR VPWR sky130_fd_sc_hd__decap_3
XFILLER_13_310 VGND VGND VPWR VPWR sky130_fd_sc_hd__decap_3
XFILLER_25_181 VGND VGND VPWR VPWR sky130_fd_sc_hd__decap_3
XFILLER_41_641 VGND VGND VPWR VPWR sky130_fd_sc_hd__decap_3
XFILLER_60_449 VGND VGND VPWR VPWR sky130_fd_sc_hd__decap_3
XFILLER_82_88 VGND VGND VPWR VPWR sky130_fd_sc_hd__decap_3
XFILLER_82_99 VGND VGND VPWR VPWR sky130_fd_sc_hd__decap_3
XFILLER_15_71 VGND VGND VPWR VPWR sky130_fd_sc_hd__fill_2
XFILLER_15_82 VGND VGND VPWR VPWR sky130_fd_sc_hd__fill_2
XFILLER_40_184 VGND VGND VPWR VPWR sky130_fd_sc_hd__decap_3
XFILLER_9_358 VGND VGND VPWR VPWR sky130_fd_sc_hd__decap_3
XTAP_TAPCELL_ROW_93_1307 VGND VPWR sky130_fd_sc_hd__tapvpwrvgnd_1
XFILLER_5_553 VGND VGND VPWR VPWR sky130_fd_sc_hd__decap_3
XFILLER_5_564 VGND VGND VPWR VPWR sky130_fd_sc_hd__decap_3
XFILLER_5_597 VGND VGND VPWR VPWR sky130_fd_sc_hd__decap_3
XFILLER_95_346 VGND VGND VPWR VPWR sky130_fd_sc_hd__decap_3
XFILLER_48_262 VGND VGND VPWR VPWR sky130_fd_sc_hd__decap_3
XFILLER_83_508 VGND VGND VPWR VPWR sky130_fd_sc_hd__decap_3
XFILLER_63_210 VGND VGND VPWR VPWR sky130_fd_sc_hd__decap_3
XFILLER_24_619 VGND VGND VPWR VPWR sky130_fd_sc_hd__decap_3
XFILLER_23_129 VGND VGND VPWR VPWR sky130_fd_sc_hd__decap_3
XFILLER_51_416 VGND VGND VPWR VPWR sky130_fd_sc_hd__decap_3
XFILLER_63_298 VGND VGND VPWR VPWR sky130_fd_sc_hd__decap_3
X_4981_ _6992_/Q _5001_/A VGND VGND VPWR VPWR _6992_/D sky130_fd_sc_hd__xor2_2
XTAP_TAPCELL_ROW_34_625 VGND VPWR sky130_fd_sc_hd__tapvpwrvgnd_1
XTAP_TAPCELL_ROW_102_1403 VGND VPWR sky130_fd_sc_hd__tapvpwrvgnd_1
Xclkbuf_leaf_43_clk clkbuf_leaf_2_clk/A VGND VGND VPWR VPWR clkload5/A sky130_fd_sc_hd__clkbuf_16
Xplace298 _3640_/X VGND VGND VPWR VPWR _3665_/B sky130_fd_sc_hd__buf_2
Xplace287 _3656_/Y VGND VGND VPWR VPWR _3893_/B1 sky130_fd_sc_hd__buf_2
Xplace276 _3661_/X VGND VGND VPWR VPWR _3852_/A2 sky130_fd_sc_hd__buf_2
Xplace265 _5116_/Y VGND VGND VPWR VPWR _5658_/D sky130_fd_sc_hd__buf_2
X_6720_ clkload5/A _6720_/D VGND VGND VPWR VPWR _6720_/Q sky130_fd_sc_hd__dfxtp_2
XTAP_TAPCELL_ROW_62_945 VGND VPWR sky130_fd_sc_hd__tapvpwrvgnd_1
XFILLER_31_151 VGND VGND VPWR VPWR sky130_fd_sc_hd__decap_3
X_6651_ _6652_/A VGND VGND VPWR VPWR _6651_/Y sky130_fd_sc_hd__inv_2
X_3863_ _6697_/Q _3884_/B1 _3912_/B1 _6875_/Q _3862_/X VGND VGND VPWR VPWR _3863_/X
+ sky130_fd_sc_hd__a221o_2
X_6582_ _6611_/A VGND VGND VPWR VPWR _6582_/Y sky130_fd_sc_hd__inv_2
X_5602_ _5602_/A _5634_/B VGND VGND VPWR VPWR _7026_/D sky130_fd_sc_hd__and2_2
X_3794_ _6774_/Q _3881_/A2 _3879_/B1 _6762_/Q _3793_/X VGND VGND VPWR VPWR _3794_/X
+ sky130_fd_sc_hd__a221o_2
XTAP_TAPCELL_ROW_14_393 VGND VPWR sky130_fd_sc_hd__tapvpwrvgnd_1
X_7203_ _7269_/CLK _7203_/D _6483_/Y VGND VGND VPWR VPWR _7203_/Q sky130_fd_sc_hd__dfrtp_2
X_4415_ _7400_/Q _4419_/B1 _4434_/B1 _7144_/Q _4414_/X VGND VGND VPWR VPWR _4415_/X
+ sky130_fd_sc_hd__a221o_2
X_7134_ _7362_/CLK _7134_/D _6414_/Y VGND VGND VPWR VPWR _7134_/Q sky130_fd_sc_hd__dfrtp_2
X_4346_ _7321_/Q _3958_/S _4346_/B1 _7353_/Q VGND VGND VPWR VPWR _4346_/X sky130_fd_sc_hd__a22o_2
XTAP_TAPCELL_ROW_6_306 VGND VPWR sky130_fd_sc_hd__tapvpwrvgnd_1
XFILLER_99_641 VGND VGND VPWR VPWR sky130_fd_sc_hd__decap_3
XFILLER_59_516 VGND VGND VPWR VPWR sky130_fd_sc_hd__fill_2
XFILLER_98_162 VGND VGND VPWR VPWR sky130_fd_sc_hd__decap_3
XFILLER_101_635 VGND VGND VPWR VPWR sky130_fd_sc_hd__decap_3
X_7065_ clkload9/A _7065_/D _6345_/Y VGND VGND VPWR VPWR _7065_/Q sky130_fd_sc_hd__dfrtp_2
X_4277_ _5003_/A _4620_/C VGND VGND VPWR VPWR _4277_/Y sky130_fd_sc_hd__nor2_2
XFILLER_100_167 VGND VGND VPWR VPWR sky130_fd_sc_hd__decap_3
XFILLER_27_435 VGND VGND VPWR VPWR sky130_fd_sc_hd__fill_2
XFILLER_39_284 VGND VGND VPWR VPWR sky130_fd_sc_hd__decap_3
XFILLER_39_295 VGND VGND VPWR VPWR sky130_fd_sc_hd__decap_3
XFILLER_54_221 VGND VGND VPWR VPWR sky130_fd_sc_hd__decap_3
XFILLER_82_530 VGND VGND VPWR VPWR sky130_fd_sc_hd__fill_2
XTAP_TAPCELL_ROW_68_1022 VGND VPWR sky130_fd_sc_hd__tapvpwrvgnd_1
XTAP_TAPCELL_ROW_68_1011 VGND VPWR sky130_fd_sc_hd__tapvpwrvgnd_1
XFILLER_27_457 VGND VGND VPWR VPWR sky130_fd_sc_hd__decap_3
XFILLER_36_48 VGND VGND VPWR VPWR sky130_fd_sc_hd__fill_1
XFILLER_14_118 VGND VGND VPWR VPWR sky130_fd_sc_hd__decap_3
XFILLER_54_276 VGND VGND VPWR VPWR sky130_fd_sc_hd__decap_3
XFILLER_82_574 VGND VGND VPWR VPWR sky130_fd_sc_hd__decap_3
XFILLER_23_641 VGND VGND VPWR VPWR sky130_fd_sc_hd__decap_3
Xclkbuf_leaf_34_clk clkbuf_3_2__f_clk/X VGND VGND VPWR VPWR _7355_/CLK sky130_fd_sc_hd__clkbuf_16
X_6918_ clkload4/A _6918_/D VGND VGND VPWR VPWR _6918_/Q sky130_fd_sc_hd__dfxtp_2
X_6849_ _6974_/CLK _6849_/D VGND VGND VPWR VPWR _6849_/Q sky130_fd_sc_hd__dfxtp_2
XPHY_EDGE_ROW_30_Left_139 VGND VGND VPWR VPWR sky130_fd_sc_hd__decap_3
XFILLER_10_302 VGND VGND VPWR VPWR sky130_fd_sc_hd__decap_3
XFILLER_10_346 VGND VGND VPWR VPWR sky130_fd_sc_hd__decap_3
XFILLER_10_368 VGND VGND VPWR VPWR sky130_fd_sc_hd__decap_3
XFILLER_22_195 VGND VGND VPWR VPWR sky130_fd_sc_hd__fill_1
XTAP_TAPCELL_ROW_79_1140 VGND VPWR sky130_fd_sc_hd__tapvpwrvgnd_1
XFILLER_2_523 VGND VGND VPWR VPWR sky130_fd_sc_hd__decap_3
XFILLER_2_545 VGND VGND VPWR VPWR sky130_fd_sc_hd__decap_3
XFILLER_77_11 VGND VGND VPWR VPWR sky130_fd_sc_hd__decap_3
XFILLER_104_462 VGND VGND VPWR VPWR sky130_fd_sc_hd__fill_1
XFILLER_2_578 VGND VGND VPWR VPWR sky130_fd_sc_hd__decap_3
XFILLER_2_589 VGND VGND VPWR VPWR sky130_fd_sc_hd__decap_3
XFILLER_77_302 VGND VGND VPWR VPWR sky130_fd_sc_hd__decap_3
XFILLER_77_55 VGND VGND VPWR VPWR sky130_fd_sc_hd__fill_1
XFILLER_77_77 VGND VGND VPWR VPWR sky130_fd_sc_hd__decap_3
XFILLER_89_184 VGND VGND VPWR VPWR sky130_fd_sc_hd__decap_3
XFILLER_77_99 VGND VGND VPWR VPWR sky130_fd_sc_hd__decap_3
XFILLER_92_305 VGND VGND VPWR VPWR sky130_fd_sc_hd__decap_3
XFILLER_18_402 VGND VGND VPWR VPWR sky130_fd_sc_hd__decap_3
XFILLER_18_435 VGND VGND VPWR VPWR sky130_fd_sc_hd__decap_3
XFILLER_58_593 VGND VGND VPWR VPWR sky130_fd_sc_hd__fill_2
XFILLER_92_338 VGND VGND VPWR VPWR sky130_fd_sc_hd__decap_3
XFILLER_45_221 VGND VGND VPWR VPWR sky130_fd_sc_hd__decap_3
Xhold1080 _7234_/Q VGND VGND VPWR VPWR _5188_/A sky130_fd_sc_hd__dlygate4sd3_1
Xhold1091 _7219_/Q VGND VGND VPWR VPWR _5219_/A sky130_fd_sc_hd__dlygate4sd3_1
XFILLER_45_276 VGND VGND VPWR VPWR sky130_fd_sc_hd__decap_3
XFILLER_45_287 VGND VGND VPWR VPWR sky130_fd_sc_hd__decap_3
XFILLER_60_213 VGND VGND VPWR VPWR sky130_fd_sc_hd__decap_3
Xclkbuf_leaf_25_clk clkload2/A VGND VGND VPWR VPWR _7374_/CLK sky130_fd_sc_hd__clkbuf_16
XFILLER_13_151 VGND VGND VPWR VPWR sky130_fd_sc_hd__decap_3
XFILLER_41_460 VGND VGND VPWR VPWR sky130_fd_sc_hd__fill_2
XFILLER_60_268 VGND VGND VPWR VPWR sky130_fd_sc_hd__decap_3
XFILLER_41_493 VGND VGND VPWR VPWR sky130_fd_sc_hd__fill_2
XFILLER_9_133 VGND VGND VPWR VPWR sky130_fd_sc_hd__decap_3
XFILLER_9_155 VGND VGND VPWR VPWR sky130_fd_sc_hd__decap_3
XTAP_TAPCELL_ROW_11_363 VGND VPWR sky130_fd_sc_hd__tapvpwrvgnd_1
XFILLER_9_199 VGND VGND VPWR VPWR sky130_fd_sc_hd__decap_3
XFILLER_61_6 VGND VGND VPWR VPWR sky130_fd_sc_hd__fill_2
X_4200_ _4950_/A _4381_/A VGND VGND VPWR VPWR _4200_/X sky130_fd_sc_hd__or2_2
XFILLER_68_346 VGND VGND VPWR VPWR sky130_fd_sc_hd__decap_3
XFILLER_95_121 VGND VGND VPWR VPWR sky130_fd_sc_hd__decap_3
X_4131_ _7267_/Q _4422_/A2 _4128_/X _4130_/X VGND VGND VPWR VPWR _4131_/X sky130_fd_sc_hd__a211o_2
XFILLER_68_368 VGND VGND VPWR VPWR sky130_fd_sc_hd__decap_3
XFILLER_83_305 VGND VGND VPWR VPWR sky130_fd_sc_hd__fill_1
XFILLER_95_165 VGND VGND VPWR VPWR sky130_fd_sc_hd__decap_3
X_4062_ _7026_/Q _4437_/A2 _3939_/S _7212_/Q _4061_/X VGND VGND VPWR VPWR _4062_/X
+ sky130_fd_sc_hd__a221o_2
XFILLER_83_327 VGND VGND VPWR VPWR sky130_fd_sc_hd__decap_3
XFILLER_83_349 VGND VGND VPWR VPWR sky130_fd_sc_hd__decap_3
XFILLER_95_187 VGND VGND VPWR VPWR sky130_fd_sc_hd__decap_3
XFILLER_95_198 VGND VGND VPWR VPWR sky130_fd_sc_hd__decap_3
XFILLER_36_221 VGND VGND VPWR VPWR sky130_fd_sc_hd__decap_3
XFILLER_64_541 VGND VGND VPWR VPWR sky130_fd_sc_hd__fill_1
XFILLER_24_416 VGND VGND VPWR VPWR sky130_fd_sc_hd__decap_3
XFILLER_36_265 VGND VGND VPWR VPWR sky130_fd_sc_hd__fill_1
XFILLER_91_371 VGND VGND VPWR VPWR sky130_fd_sc_hd__decap_3
XTAP_TAPCELL_ROW_47_772 VGND VPWR sky130_fd_sc_hd__tapvpwrvgnd_1
XTAP_TAPCELL_ROW_19_452 VGND VPWR sky130_fd_sc_hd__tapvpwrvgnd_1
XFILLER_91_393 VGND VGND VPWR VPWR sky130_fd_sc_hd__decap_3
Xclkbuf_leaf_16_clk clkload1/A VGND VGND VPWR VPWR _7405_/CLK sky130_fd_sc_hd__clkbuf_16
X_4964_ _5092_/C _4961_/X _6994_/D _5666_/A VGND VGND VPWR VPWR _4964_/X sky130_fd_sc_hd__a22o_2
XFILLER_51_279 VGND VGND VPWR VPWR sky130_fd_sc_hd__fill_1
X_6703_ _7361_/CLK _6703_/D VGND VGND VPWR VPWR _6703_/Q sky130_fd_sc_hd__dfxtp_2
X_3915_ _7378_/Q _3914_/X _5138_/S VGND VGND VPWR VPWR _7378_/D sky130_fd_sc_hd__mux2_2
XFILLER_20_622 VGND VGND VPWR VPWR sky130_fd_sc_hd__decap_3
XFILLER_32_471 VGND VGND VPWR VPWR sky130_fd_sc_hd__fill_1
X_4895_ _6997_/Q _5622_/B _4909_/B VGND VGND VPWR VPWR _4896_/B sky130_fd_sc_hd__a21o_2
X_6634_ _6636_/A VGND VGND VPWR VPWR _6634_/Y sky130_fd_sc_hd__inv_2
X_3846_ _6964_/Q _3886_/A2 _3886_/B1 _6952_/Q VGND VGND VPWR VPWR _3846_/X sky130_fd_sc_hd__a22o_2
X_6565_ _6566_/A VGND VGND VPWR VPWR _6565_/Y sky130_fd_sc_hd__inv_2
X_3777_ _6972_/Q _3887_/A2 _3887_/B1 _6722_/Q _3776_/X VGND VGND VPWR VPWR _3777_/X
+ sky130_fd_sc_hd__a221o_2
X_6496_ _6635_/A VGND VGND VPWR VPWR _6496_/Y sky130_fd_sc_hd__inv_2
XFILLER_105_215 VGND VGND VPWR VPWR sky130_fd_sc_hd__decap_3
XFILLER_105_237 VGND VGND VPWR VPWR sky130_fd_sc_hd__fill_2
XFILLER_87_600 VGND VGND VPWR VPWR sky130_fd_sc_hd__decap_3
Xoutput496 _3394_/A VGND VGND VPWR VPWR instruction_out[16] sky130_fd_sc_hd__clkdlybuf4s25_1
Xoutput485 _3746_/C VGND VGND VPWR VPWR alu_result_out[5] sky130_fd_sc_hd__clkdlybuf4s25_1
Xoutput474 _5657_/A VGND VGND VPWR VPWR alu_result_out[24] sky130_fd_sc_hd__clkdlybuf4s25_1
Xoutput463 _5662_/A VGND VGND VPWR VPWR alu_result_out[14] sky130_fd_sc_hd__clkdlybuf4s25_1
XTAP_TAPCELL_ROW_74_1081 VGND VPWR sky130_fd_sc_hd__tapvpwrvgnd_1
XFILLER_101_410 VGND VGND VPWR VPWR sky130_fd_sc_hd__decap_3
XFILLER_59_324 VGND VGND VPWR VPWR sky130_fd_sc_hd__decap_3
XFILLER_87_644 VGND VGND VPWR VPWR sky130_fd_sc_hd__decap_3
X_7117_ _7373_/CLK _7117_/D _6397_/Y VGND VGND VPWR VPWR _7117_/Q sky130_fd_sc_hd__dfrtp_2
X_4329_ _4362_/C _4362_/A _4362_/B VGND VGND VPWR VPWR _4330_/B sky130_fd_sc_hd__and3b_2
XFILLER_101_443 VGND VGND VPWR VPWR sky130_fd_sc_hd__decap_3
X_7048_ _7269_/CLK _7048_/D _6328_/Y VGND VGND VPWR VPWR _7048_/Q sky130_fd_sc_hd__dfrtp_2
XFILLER_101_476 VGND VGND VPWR VPWR sky130_fd_sc_hd__decap_3
XFILLER_27_221 VGND VGND VPWR VPWR sky130_fd_sc_hd__decap_3
XFILLER_74_349 VGND VGND VPWR VPWR sky130_fd_sc_hd__decap_3
XFILLER_15_405 VGND VGND VPWR VPWR sky130_fd_sc_hd__fill_1
XFILLER_15_427 VGND VGND VPWR VPWR sky130_fd_sc_hd__decap_3
XFILLER_27_265 VGND VGND VPWR VPWR sky130_fd_sc_hd__decap_3
XFILLER_15_449 VGND VGND VPWR VPWR sky130_fd_sc_hd__decap_3
XFILLER_27_298 VGND VGND VPWR VPWR sky130_fd_sc_hd__decap_3
XFILLER_42_224 VGND VGND VPWR VPWR sky130_fd_sc_hd__decap_3
XFILLER_42_246 VGND VGND VPWR VPWR sky130_fd_sc_hd__decap_3
XFILLER_63_35 VGND VGND VPWR VPWR sky130_fd_sc_hd__fill_2
XFILLER_63_57 VGND VGND VPWR VPWR sky130_fd_sc_hd__decap_3
XFILLER_70_533 VGND VGND VPWR VPWR sky130_fd_sc_hd__decap_3
XFILLER_11_600 VGND VGND VPWR VPWR sky130_fd_sc_hd__decap_3
XFILLER_30_419 VGND VGND VPWR VPWR sky130_fd_sc_hd__fill_1
XFILLER_11_644 VGND VGND VPWR VPWR sky130_fd_sc_hd__decap_3
XFILLER_7_615 VGND VGND VPWR VPWR sky130_fd_sc_hd__fill_1
XFILLER_7_626 VGND VGND VPWR VPWR sky130_fd_sc_hd__decap_3
XFILLER_10_187 VGND VGND VPWR VPWR sky130_fd_sc_hd__decap_3
XFILLER_12_61 VGND VGND VPWR VPWR sky130_fd_sc_hd__decap_3
XFILLER_6_169 VGND VGND VPWR VPWR sky130_fd_sc_hd__decap_3
XFILLER_97_408 VGND VGND VPWR VPWR sky130_fd_sc_hd__decap_3
XFILLER_78_611 VGND VGND VPWR VPWR sky130_fd_sc_hd__decap_3
XFILLER_2_386 VGND VGND VPWR VPWR sky130_fd_sc_hd__decap_3
XFILLER_38_519 VGND VGND VPWR VPWR sky130_fd_sc_hd__decap_3
XFILLER_77_143 VGND VGND VPWR VPWR sky130_fd_sc_hd__decap_3
XFILLER_77_187 VGND VGND VPWR VPWR sky130_fd_sc_hd__decap_3
XFILLER_92_113 VGND VGND VPWR VPWR sky130_fd_sc_hd__decap_3
XFILLER_93_647 VGND VGND VPWR VPWR sky130_fd_sc_hd__fill_1
XFILLER_18_243 VGND VGND VPWR VPWR sky130_fd_sc_hd__decap_3
XFILLER_46_552 VGND VGND VPWR VPWR sky130_fd_sc_hd__fill_2
XFILLER_61_511 VGND VGND VPWR VPWR sky130_fd_sc_hd__decap_3
XFILLER_92_168 VGND VGND VPWR VPWR sky130_fd_sc_hd__decap_3
XFILLER_18_287 VGND VGND VPWR VPWR sky130_fd_sc_hd__decap_3
XFILLER_33_213 VGND VGND VPWR VPWR sky130_fd_sc_hd__decap_3
XFILLER_73_382 VGND VGND VPWR VPWR sky130_fd_sc_hd__decap_3
XFILLER_73_393 VGND VGND VPWR VPWR sky130_fd_sc_hd__decap_3
XTAP_TAPCELL_ROW_44_742 VGND VPWR sky130_fd_sc_hd__tapvpwrvgnd_1
XTAP_TAPCELL_ROW_16_422 VGND VPWR sky130_fd_sc_hd__tapvpwrvgnd_1
XFILLER_33_279 VGND VGND VPWR VPWR sky130_fd_sc_hd__fill_1
XFILLER_61_599 VGND VGND VPWR VPWR sky130_fd_sc_hd__decap_3
X_3700_ _6939_/Q _3884_/A2 _3824_/B1 _6803_/Q _3699_/X VGND VGND VPWR VPWR _3700_/X
+ sky130_fd_sc_hd__a221o_2
X_4680_ _4680_/A _5015_/B VGND VGND VPWR VPWR _5009_/A sky130_fd_sc_hd__nor2_2
X_3631_ _3630_/A _3630_/B _5146_/B1 VGND VGND VPWR VPWR _3631_/Y sky130_fd_sc_hd__o21ai_2
XTAP_TAPCELL_ROW_99_1368 VGND VPWR sky130_fd_sc_hd__tapvpwrvgnd_1
X_6350_ _6677_/A VGND VGND VPWR VPWR _6350_/Y sky130_fd_sc_hd__inv_2
X_3562_ _3562_/A _3562_/B _3561_/X VGND VGND VPWR VPWR _5362_/C sky130_fd_sc_hd__or3b_2
X_6281_ _6397_/A VGND VGND VPWR VPWR _6281_/Y sky130_fd_sc_hd__inv_2
X_3493_ _7087_/Q _3417_/X _3407_/X _7119_/Q VGND VGND VPWR VPWR _3493_/X sky130_fd_sc_hd__a22o_2
Xclkbuf_leaf_5_clk clkbuf_leaf_7_clk/A VGND VGND VPWR VPWR clkload8/A sky130_fd_sc_hd__clkbuf_16
X_5232_ hold994/X _4716_/X _5274_/S VGND VGND VPWR VPWR _7214_/D sky130_fd_sc_hd__mux2_2
XFILLER_102_229 VGND VGND VPWR VPWR sky130_fd_sc_hd__decap_3
XFILLER_69_644 VGND VGND VPWR VPWR sky130_fd_sc_hd__decap_3
X_5163_ _5163_/A _5186_/B VGND VGND VPWR VPWR _7246_/D sky130_fd_sc_hd__and2_2
XFILLER_29_508 VGND VGND VPWR VPWR sky130_fd_sc_hd__decap_3
X_4114_ _7172_/Q _4261_/B1 _4420_/B1 _7140_/Q _4113_/X VGND VGND VPWR VPWR _4114_/X
+ sky130_fd_sc_hd__a221o_2
XFILLER_68_165 VGND VGND VPWR VPWR sky130_fd_sc_hd__decap_3
XFILLER_83_113 VGND VGND VPWR VPWR sky130_fd_sc_hd__fill_1
X_5094_ _5666_/A _6986_/D _5093_/X VGND VGND VPWR VPWR _5094_/X sky130_fd_sc_hd__a21o_2
XFILLER_37_530 VGND VGND VPWR VPWR sky130_fd_sc_hd__decap_3
XFILLER_83_146 VGND VGND VPWR VPWR sky130_fd_sc_hd__decap_3
X_4045_ _7085_/Q _4102_/B _4432_/B1 _4044_/X VGND VGND VPWR VPWR _4054_/A sky130_fd_sc_hd__o211a_2
XFILLER_71_308 VGND VGND VPWR VPWR sky130_fd_sc_hd__decap_3
XTAP_TAPCELL_ROW_108_1475 VGND VPWR sky130_fd_sc_hd__tapvpwrvgnd_1
XFILLER_24_224 VGND VGND VPWR VPWR sky130_fd_sc_hd__decap_3
XTAP_TAPCELL_ROW_108_1486 VGND VPWR sky130_fd_sc_hd__tapvpwrvgnd_1
XFILLER_12_408 VGND VGND VPWR VPWR sky130_fd_sc_hd__fill_1
XFILLER_33_27 VGND VGND VPWR VPWR sky130_fd_sc_hd__decap_3
XFILLER_32_290 VGND VGND VPWR VPWR sky130_fd_sc_hd__decap_3
X_4878_ _4878_/A1 _6999_/D _4870_/Y _4877_/X VGND VGND VPWR VPWR _4878_/X sky130_fd_sc_hd__a211o_2
X_6617_ _6619_/A VGND VGND VPWR VPWR _6617_/Y sky130_fd_sc_hd__inv_2
X_3829_ _6908_/Q _3884_/A2 _3881_/B1 _6900_/Q VGND VGND VPWR VPWR _3829_/X sky130_fd_sc_hd__a22o_2
XPHY_EDGE_ROW_104_Left_213 VGND VGND VPWR VPWR sky130_fd_sc_hd__decap_3
XFILLER_4_607 VGND VGND VPWR VPWR sky130_fd_sc_hd__decap_3
XFILLER_106_524 VGND VGND VPWR VPWR sky130_fd_sc_hd__decap_3
X_6548_ _6646_/A VGND VGND VPWR VPWR _6548_/Y sky130_fd_sc_hd__inv_2
XTAP_TAPCELL_ROW_76_1110 VGND VPWR sky130_fd_sc_hd__tapvpwrvgnd_1
X_6479_ _6646_/A VGND VGND VPWR VPWR _6479_/Y sky130_fd_sc_hd__inv_2
XFILLER_101_240 VGND VGND VPWR VPWR sky130_fd_sc_hd__decap_3
XFILLER_58_68 VGND VGND VPWR VPWR sky130_fd_sc_hd__decap_3
XFILLER_101_262 VGND VGND VPWR VPWR sky130_fd_sc_hd__fill_2
XFILLER_101_284 VGND VGND VPWR VPWR sky130_fd_sc_hd__decap_3
XFILLER_74_113 VGND VGND VPWR VPWR sky130_fd_sc_hd__fill_1
XFILLER_75_647 VGND VGND VPWR VPWR sky130_fd_sc_hd__fill_1
XFILLER_28_530 VGND VGND VPWR VPWR sky130_fd_sc_hd__fill_2
XFILLER_74_124 VGND VGND VPWR VPWR sky130_fd_sc_hd__decap_3
XFILLER_15_202 VGND VGND VPWR VPWR sky130_fd_sc_hd__decap_3
XFILLER_74_168 VGND VGND VPWR VPWR sky130_fd_sc_hd__decap_3
XFILLER_90_639 VGND VGND VPWR VPWR sky130_fd_sc_hd__decap_3
XFILLER_55_371 VGND VGND VPWR VPWR sky130_fd_sc_hd__decap_3
XFILLER_55_393 VGND VGND VPWR VPWR sky130_fd_sc_hd__decap_3
XFILLER_15_257 VGND VGND VPWR VPWR sky130_fd_sc_hd__decap_3
XFILLER_30_227 VGND VGND VPWR VPWR sky130_fd_sc_hd__decap_3
XFILLER_70_374 VGND VGND VPWR VPWR sky130_fd_sc_hd__decap_3
XTAP_TAPCELL_ROW_41_701 VGND VPWR sky130_fd_sc_hd__tapvpwrvgnd_1
XFILLER_11_452 VGND VGND VPWR VPWR sky130_fd_sc_hd__decap_3
XTAP_TAPCELL_ROW_21_480 VGND VPWR sky130_fd_sc_hd__tapvpwrvgnd_1
XFILLER_99_31 VGND VGND VPWR VPWR sky130_fd_sc_hd__decap_3
XFILLER_2_150 VGND VGND VPWR VPWR sky130_fd_sc_hd__decap_3
XFILLER_2_183 VGND VGND VPWR VPWR sky130_fd_sc_hd__decap_3
XFILLER_66_603 VGND VGND VPWR VPWR sky130_fd_sc_hd__fill_1
XFILLER_38_305 VGND VGND VPWR VPWR sky130_fd_sc_hd__decap_3
XFILLER_65_113 VGND VGND VPWR VPWR sky130_fd_sc_hd__fill_1
XFILLER_66_625 VGND VGND VPWR VPWR sky130_fd_sc_hd__decap_3
Xsingle_cycle_cpu_575 VGND VGND VPWR VPWR single_cycle_cpu_575/HI instruction_out[29]
+ sky130_fd_sc_hd__conb_1
XTAP_TAPCELL_ROW_49_801 VGND VPWR sky130_fd_sc_hd__tapvpwrvgnd_1
XFILLER_0_20 VGND VGND VPWR VPWR sky130_fd_sc_hd__fill_1
XFILLER_38_338 VGND VGND VPWR VPWR sky130_fd_sc_hd__decap_3
XFILLER_93_444 VGND VGND VPWR VPWR sky130_fd_sc_hd__decap_3
XFILLER_46_360 VGND VGND VPWR VPWR sky130_fd_sc_hd__decap_3
XFILLER_53_308 VGND VGND VPWR VPWR sky130_fd_sc_hd__decap_3
XFILLER_53_319 VGND VGND VPWR VPWR sky130_fd_sc_hd__decap_3
XFILLER_34_533 VGND VGND VPWR VPWR sky130_fd_sc_hd__decap_3
XFILLER_46_371 VGND VGND VPWR VPWR sky130_fd_sc_hd__decap_3
XFILLER_80_127 VGND VGND VPWR VPWR sky130_fd_sc_hd__decap_3
XFILLER_61_352 VGND VGND VPWR VPWR sky130_fd_sc_hd__decap_3
XFILLER_21_216 VGND VGND VPWR VPWR sky130_fd_sc_hd__decap_3
XFILLER_61_385 VGND VGND VPWR VPWR sky130_fd_sc_hd__decap_3
XFILLER_61_396 VGND VGND VPWR VPWR sky130_fd_sc_hd__decap_3
X_4801_ _4801_/A _4801_/B VGND VGND VPWR VPWR _7003_/D sky130_fd_sc_hd__nor2_2
X_4663_ _4764_/B _4040_/B _4608_/Y _4659_/X _4662_/Y VGND VGND VPWR VPWR _5665_/A
+ sky130_fd_sc_hd__o32a_2
XFILLER_9_95 VGND VGND VPWR VPWR sky130_fd_sc_hd__fill_1
X_6402_ _6592_/A VGND VGND VPWR VPWR _6402_/Y sky130_fd_sc_hd__inv_2
X_3614_ _3614_/A _3614_/B VGND VGND VPWR VPWR _3746_/B sky130_fd_sc_hd__and2_2
X_7382_ _7382_/CLK _7382_/D _6662_/Y VGND VGND VPWR VPWR _7382_/Q sky130_fd_sc_hd__dfrtp_2
Xhold902 _7057_/Q VGND VGND VPWR VPWR _7057_/D sky130_fd_sc_hd__dlygate4sd3_1
Xhold913 _6717_/Q VGND VGND VPWR VPWR hold913/X sky130_fd_sc_hd__dlygate4sd3_1
Xhold924 _7033_/Q VGND VGND VPWR VPWR _5589_/A sky130_fd_sc_hd__dlygate4sd3_1
Xhold946 _7050_/Q VGND VGND VPWR VPWR hold946/X sky130_fd_sc_hd__dlygate4sd3_1
Xhold935 _6708_/Q VGND VGND VPWR VPWR hold935/X sky130_fd_sc_hd__dlygate4sd3_1
X_6333_ _6650_/A VGND VGND VPWR VPWR _6333_/Y sky130_fd_sc_hd__inv_2
X_3545_ _3545_/A _3545_/B VGND VGND VPWR VPWR _3636_/A sky130_fd_sc_hd__nor2_2
XFILLER_103_505 VGND VGND VPWR VPWR sky130_fd_sc_hd__decap_3
XFILLER_88_205 VGND VGND VPWR VPWR sky130_fd_sc_hd__decap_3
Xhold979 _7325_/Q VGND VGND VPWR VPWR hold979/X sky130_fd_sc_hd__dlygate4sd3_1
Xhold968 _7026_/Q VGND VGND VPWR VPWR _5602_/A sky130_fd_sc_hd__dlygate4sd3_1
Xhold957 _7315_/Q VGND VGND VPWR VPWR _4528_/A sky130_fd_sc_hd__dlygate4sd3_1
X_6264_ _6344_/A VGND VGND VPWR VPWR _6264_/Y sky130_fd_sc_hd__inv_2
X_3476_ _7056_/Q _4305_/B _3429_/X VGND VGND VPWR VPWR _3502_/B sky130_fd_sc_hd__o21ai_2
X_5215_ _5215_/A _5225_/B VGND VGND VPWR VPWR _7221_/D sky130_fd_sc_hd__and2_2
XTAP_TAPCELL_ROW_71_1051 VGND VPWR sky130_fd_sc_hd__tapvpwrvgnd_1
XFILLER_56_102 VGND VGND VPWR VPWR sky130_fd_sc_hd__decap_3
X_5146_ _5145_/A _3541_/X _5146_/B1 VGND VGND VPWR VPWR _5146_/Y sky130_fd_sc_hd__o21ai_2
XFILLER_56_135 VGND VGND VPWR VPWR sky130_fd_sc_hd__decap_3
XFILLER_57_647 VGND VGND VPWR VPWR sky130_fd_sc_hd__fill_1
XFILLER_84_455 VGND VGND VPWR VPWR sky130_fd_sc_hd__decap_3
X_5077_ _3864_/S _3863_/X _5658_/A VGND VGND VPWR VPWR _5077_/X sky130_fd_sc_hd__a21o_2
XFILLER_71_105 VGND VGND VPWR VPWR sky130_fd_sc_hd__decap_3
XFILLER_72_639 VGND VGND VPWR VPWR sky130_fd_sc_hd__decap_3
XFILLER_25_511 VGND VGND VPWR VPWR sky130_fd_sc_hd__decap_3
XFILLER_71_149 VGND VGND VPWR VPWR sky130_fd_sc_hd__decap_3
XFILLER_25_577 VGND VGND VPWR VPWR sky130_fd_sc_hd__fill_2
XFILLER_52_352 VGND VGND VPWR VPWR sky130_fd_sc_hd__decap_3
XFILLER_64_190 VGND VGND VPWR VPWR sky130_fd_sc_hd__decap_3
XFILLER_12_227 VGND VGND VPWR VPWR sky130_fd_sc_hd__decap_3
XFILLER_40_503 VGND VGND VPWR VPWR sky130_fd_sc_hd__fill_2
XFILLER_40_536 VGND VGND VPWR VPWR sky130_fd_sc_hd__decap_3
XFILLER_52_374 VGND VGND VPWR VPWR sky130_fd_sc_hd__fill_1
XFILLER_100_32 VGND VGND VPWR VPWR sky130_fd_sc_hd__decap_3
XFILLER_40_569 VGND VGND VPWR VPWR sky130_fd_sc_hd__decap_3
XTAP_TAPCELL_ROW_82_1180 VGND VPWR sky130_fd_sc_hd__tapvpwrvgnd_1
XFILLER_106_321 VGND VGND VPWR VPWR sky130_fd_sc_hd__fill_2
XFILLER_79_205 VGND VGND VPWR VPWR sky130_fd_sc_hd__decap_3
XFILLER_0_632 VGND VGND VPWR VPWR sky130_fd_sc_hd__decap_3
XFILLER_47_113 VGND VGND VPWR VPWR sky130_fd_sc_hd__decap_3
XFILLER_48_625 VGND VGND VPWR VPWR sky130_fd_sc_hd__decap_3
XFILLER_85_11 VGND VGND VPWR VPWR sky130_fd_sc_hd__fill_1
XFILLER_47_146 VGND VGND VPWR VPWR sky130_fd_sc_hd__decap_3
XFILLER_75_455 VGND VGND VPWR VPWR sky130_fd_sc_hd__fill_2
XFILLER_85_55 VGND VGND VPWR VPWR sky130_fd_sc_hd__fill_1
XFILLER_18_71 VGND VGND VPWR VPWR sky130_fd_sc_hd__fill_1
XFILLER_63_617 VGND VGND VPWR VPWR sky130_fd_sc_hd__decap_3
XFILLER_90_414 VGND VGND VPWR VPWR sky130_fd_sc_hd__decap_3
XTAP_TAPCELL_ROW_85_1209 VGND VPWR sky130_fd_sc_hd__tapvpwrvgnd_1
XFILLER_16_522 VGND VGND VPWR VPWR sky130_fd_sc_hd__fill_2
XFILLER_16_533 VGND VGND VPWR VPWR sky130_fd_sc_hd__fill_2
XFILLER_62_116 VGND VGND VPWR VPWR sky130_fd_sc_hd__fill_2
XFILLER_62_138 VGND VGND VPWR VPWR sky130_fd_sc_hd__fill_2
XFILLER_16_544 VGND VGND VPWR VPWR sky130_fd_sc_hd__fill_1
XFILLER_16_566 VGND VGND VPWR VPWR sky130_fd_sc_hd__decap_3
XFILLER_55_190 VGND VGND VPWR VPWR sky130_fd_sc_hd__decap_3
XFILLER_16_577 VGND VGND VPWR VPWR sky130_fd_sc_hd__decap_3
XFILLER_31_503 VGND VGND VPWR VPWR sky130_fd_sc_hd__fill_1
XFILLER_11_260 VGND VGND VPWR VPWR sky130_fd_sc_hd__decap_3
XFILLER_11_293 VGND VGND VPWR VPWR sky130_fd_sc_hd__decap_3
XFILLER_7_231 VGND VGND VPWR VPWR sky130_fd_sc_hd__decap_3
XFILLER_7_264 VGND VGND VPWR VPWR sky130_fd_sc_hd__decap_3
XTAP_TAPCELL_ROW_96_1338 VGND VPWR sky130_fd_sc_hd__tapvpwrvgnd_1
XFILLER_7_297 VGND VGND VPWR VPWR sky130_fd_sc_hd__decap_3
X_3330_ _3340_/A VGND VGND VPWR VPWR _3330_/Y sky130_fd_sc_hd__inv_2
XFILLER_98_503 VGND VGND VPWR VPWR sky130_fd_sc_hd__fill_1
XFILLER_98_536 VGND VGND VPWR VPWR sky130_fd_sc_hd__decap_3
XFILLER_100_508 VGND VGND VPWR VPWR sky130_fd_sc_hd__decap_3
X_5000_ _6991_/Q _5026_/A VGND VGND VPWR VPWR _5001_/B sky130_fd_sc_hd__nor2_2
XFILLER_22_3 VGND VGND VPWR VPWR sky130_fd_sc_hd__decap_3
Xsingle_cycle_cpu VGND VGND VPWR VPWR single_cycle_cpu/HI instruction_out[19] sky130_fd_sc_hd__conb_1
XFILLER_39_647 VGND VGND VPWR VPWR sky130_fd_sc_hd__fill_1
XFILLER_66_444 VGND VGND VPWR VPWR sky130_fd_sc_hd__decap_3
XFILLER_93_230 VGND VGND VPWR VPWR sky130_fd_sc_hd__decap_3
XFILLER_53_105 VGND VGND VPWR VPWR sky130_fd_sc_hd__decap_3
XFILLER_54_617 VGND VGND VPWR VPWR sky130_fd_sc_hd__decap_3
XFILLER_81_403 VGND VGND VPWR VPWR sky130_fd_sc_hd__decap_3
XFILLER_93_274 VGND VGND VPWR VPWR sky130_fd_sc_hd__fill_2
XFILLER_53_138 VGND VGND VPWR VPWR sky130_fd_sc_hd__decap_3
XFILLER_81_447 VGND VGND VPWR VPWR sky130_fd_sc_hd__fill_1
X_6951_ _6963_/CLK _6951_/D VGND VGND VPWR VPWR _6951_/Q sky130_fd_sc_hd__dfxtp_2
X_6882_ clkload5/A _6882_/D VGND VGND VPWR VPWR _6882_/Q sky130_fd_sc_hd__dfxtp_2
XTAP_TAPCELL_ROW_24_509 VGND VPWR sky130_fd_sc_hd__tapvpwrvgnd_1
XTAP_TAPCELL_ROW_105_1445 VGND VPWR sky130_fd_sc_hd__tapvpwrvgnd_1
XFILLER_34_374 VGND VGND VPWR VPWR sky130_fd_sc_hd__fill_2
XTAP_TAPCELL_ROW_52_829 VGND VPWR sky130_fd_sc_hd__tapvpwrvgnd_1
XFILLER_14_29 VGND VGND VPWR VPWR sky130_fd_sc_hd__decap_3
XFILLER_34_396 VGND VGND VPWR VPWR sky130_fd_sc_hd__decap_3
XFILLER_108_608 VGND VGND VPWR VPWR sky130_fd_sc_hd__decap_3
X_5695_ _7353_/Q hold929/X _5721_/S VGND VGND VPWR VPWR _6697_/D sky130_fd_sc_hd__mux2_2
XTAP_TAPCELL_ROW_32_597 VGND VPWR sky130_fd_sc_hd__tapvpwrvgnd_1
X_4646_ _4646_/A _4646_/B VGND VGND VPWR VPWR _4646_/Y sky130_fd_sc_hd__nand2_2
X_7365_ _7366_/CLK _7365_/D _6645_/Y VGND VGND VPWR VPWR _7365_/Q sky130_fd_sc_hd__dfrtp_2
Xhold710 _6962_/Q VGND VGND VPWR VPWR _6962_/D sky130_fd_sc_hd__dlygate4sd3_1
Xhold721 _6897_/Q VGND VGND VPWR VPWR _6897_/D sky130_fd_sc_hd__dlygate4sd3_1
X_4577_ _4577_/A _4589_/B VGND VGND VPWR VPWR _7292_/D sky130_fd_sc_hd__and2_2
Xhold732 _6978_/Q VGND VGND VPWR VPWR _6978_/D sky130_fd_sc_hd__dlygate4sd3_1
Xhold743 _6765_/Q VGND VGND VPWR VPWR _6765_/D sky130_fd_sc_hd__dlygate4sd3_1
Xhold754 _6963_/Q VGND VGND VPWR VPWR _6963_/D sky130_fd_sc_hd__dlygate4sd3_1
X_6316_ _6536_/A VGND VGND VPWR VPWR _6316_/Y sky130_fd_sc_hd__inv_2
XFILLER_103_302 VGND VGND VPWR VPWR sky130_fd_sc_hd__decap_3
X_7296_ _7364_/CLK _7296_/D _6576_/Y VGND VGND VPWR VPWR _7296_/Q sky130_fd_sc_hd__dfrtp_2
Xhold765 _6954_/Q VGND VGND VPWR VPWR _6954_/D sky130_fd_sc_hd__dlygate4sd3_1
Xhold776 _6971_/Q VGND VGND VPWR VPWR _6971_/D sky130_fd_sc_hd__dlygate4sd3_1
Xhold787 _6890_/Q VGND VGND VPWR VPWR _6890_/D sky130_fd_sc_hd__dlygate4sd3_1
X_3528_ _3528_/A _5118_/D VGND VGND VPWR VPWR _5659_/A sky130_fd_sc_hd__or2_2
XFILLER_103_335 VGND VGND VPWR VPWR sky130_fd_sc_hd__fill_1
XFILLER_103_346 VGND VGND VPWR VPWR sky130_fd_sc_hd__decap_3
Xhold798 _6780_/Q VGND VGND VPWR VPWR _6780_/D sky130_fd_sc_hd__dlygate4sd3_1
X_3459_ _7217_/Q _4349_/B1 _4348_/B1 _7121_/Q VGND VGND VPWR VPWR _3459_/X sky130_fd_sc_hd__a22o_2
XFILLER_103_379 VGND VGND VPWR VPWR sky130_fd_sc_hd__decap_3
XFILLER_57_411 VGND VGND VPWR VPWR sky130_fd_sc_hd__decap_3
XFILLER_69_293 VGND VGND VPWR VPWR sky130_fd_sc_hd__decap_3
X_5129_ _5129_/A _5129_/B VGND VGND VPWR VPWR _5130_/C sky130_fd_sc_hd__nor2_2
XFILLER_45_617 VGND VGND VPWR VPWR sky130_fd_sc_hd__decap_3
XFILLER_57_488 VGND VGND VPWR VPWR sky130_fd_sc_hd__decap_3
XTAP_TAPCELL_ROW_4_278 VGND VPWR sky130_fd_sc_hd__tapvpwrvgnd_1
XFILLER_44_105 VGND VGND VPWR VPWR sky130_fd_sc_hd__decap_3
XFILLER_44_138 VGND VGND VPWR VPWR sky130_fd_sc_hd__fill_2
XFILLER_60_609 VGND VGND VPWR VPWR sky130_fd_sc_hd__decap_3
XFILLER_25_385 VGND VGND VPWR VPWR sky130_fd_sc_hd__decap_3
XFILLER_52_171 VGND VGND VPWR VPWR sky130_fd_sc_hd__decap_3
XFILLER_13_547 VGND VGND VPWR VPWR sky130_fd_sc_hd__fill_2
XFILLER_71_57 VGND VGND VPWR VPWR sky130_fd_sc_hd__decap_3
XFILLER_4_212 VGND VGND VPWR VPWR sky130_fd_sc_hd__decap_3
XFILLER_4_223 VGND VGND VPWR VPWR sky130_fd_sc_hd__decap_3
XFILLER_4_256 VGND VGND VPWR VPWR sky130_fd_sc_hd__decap_3
XFILLER_4_278 VGND VGND VPWR VPWR sky130_fd_sc_hd__decap_3
XFILLER_0_440 VGND VGND VPWR VPWR sky130_fd_sc_hd__decap_3
XTAP_TAPCELL_ROW_91_1279 VGND VPWR sky130_fd_sc_hd__tapvpwrvgnd_1
XFILLER_0_473 VGND VGND VPWR VPWR sky130_fd_sc_hd__decap_3
XFILLER_96_54 VGND VGND VPWR VPWR sky130_fd_sc_hd__decap_3
XFILLER_36_617 VGND VGND VPWR VPWR sky130_fd_sc_hd__decap_3
XFILLER_75_241 VGND VGND VPWR VPWR sky130_fd_sc_hd__decap_3
XFILLER_63_436 VGND VGND VPWR VPWR sky130_fd_sc_hd__decap_3
XFILLER_75_274 VGND VGND VPWR VPWR sky130_fd_sc_hd__decap_3
XFILLER_90_211 VGND VGND VPWR VPWR sky130_fd_sc_hd__decap_3
Xplace403 _4495_/S VGND VGND VPWR VPWR _4520_/S sky130_fd_sc_hd__buf_2
XFILLER_16_341 VGND VGND VPWR VPWR sky130_fd_sc_hd__decap_3
Xplace414 _3380_/Y VGND VGND VPWR VPWR _4354_/B1 sky130_fd_sc_hd__buf_2
Xplace425 _3994_/S VGND VGND VPWR VPWR _3996_/S sky130_fd_sc_hd__buf_2
Xplace436 _5581_/S VGND VGND VPWR VPWR _4983_/A sky130_fd_sc_hd__buf_2
Xplace447 _6983_/Q VGND VGND VPWR VPWR _5670_/A sky130_fd_sc_hd__buf_2
XFILLER_16_374 VGND VGND VPWR VPWR sky130_fd_sc_hd__fill_1
XFILLER_16_385 VGND VGND VPWR VPWR sky130_fd_sc_hd__decap_3
XFILLER_31_300 VGND VGND VPWR VPWR sky130_fd_sc_hd__fill_1
XFILLER_90_266 VGND VGND VPWR VPWR sky130_fd_sc_hd__decap_3
XFILLER_71_491 VGND VGND VPWR VPWR sky130_fd_sc_hd__decap_3
XFILLER_31_399 VGND VGND VPWR VPWR sky130_fd_sc_hd__decap_3
XTAP_TAPCELL_ROW_100_1386 VGND VPWR sky130_fd_sc_hd__tapvpwrvgnd_1
XANTENNA_1 _7361_/Q VGND VGND VPWR VPWR sky130_fd_sc_hd__diode_2
XFILLER_8_584 VGND VGND VPWR VPWR sky130_fd_sc_hd__decap_3
XFILLER_8_595 VGND VGND VPWR VPWR sky130_fd_sc_hd__decap_3
X_4431_ _7271_/Q _4437_/A2 _4428_/X _4430_/X VGND VGND VPWR VPWR _4431_/X sky130_fd_sc_hd__a211o_2
XFILLER_6_85 VGND VGND VPWR VPWR sky130_fd_sc_hd__decap_3
X_7150_ _7363_/CLK _7150_/D _6430_/Y VGND VGND VPWR VPWR _7150_/Q sky130_fd_sc_hd__dfrtp_2
X_4362_ _4362_/A _4362_/B _4362_/C VGND VGND VPWR VPWR _4362_/X sky130_fd_sc_hd__and3_2
XFILLER_98_300 VGND VGND VPWR VPWR sky130_fd_sc_hd__decap_3
X_7081_ _7405_/CLK _7081_/D _6361_/Y VGND VGND VPWR VPWR _7081_/Q sky130_fd_sc_hd__dfrtp_2
X_4293_ _4612_/A _4612_/B VGND VGND VPWR VPWR _4293_/X sky130_fd_sc_hd__and2b_2
X_3313_ _4697_/A _6980_/Q _3371_/A _6982_/Q VGND VGND VPWR VPWR _4467_/B sky130_fd_sc_hd__nand4b_4
XFILLER_98_344 VGND VGND VPWR VPWR sky130_fd_sc_hd__decap_3
XFILLER_100_349 VGND VGND VPWR VPWR sky130_fd_sc_hd__decap_3
XFILLER_27_606 VGND VGND VPWR VPWR sky130_fd_sc_hd__decap_3
XFILLER_27_617 VGND VGND VPWR VPWR sky130_fd_sc_hd__decap_3
XFILLER_39_466 VGND VGND VPWR VPWR sky130_fd_sc_hd__decap_3
XFILLER_66_241 VGND VGND VPWR VPWR sky130_fd_sc_hd__decap_3
XFILLER_94_572 VGND VGND VPWR VPWR sky130_fd_sc_hd__decap_3
XFILLER_26_105 VGND VGND VPWR VPWR sky130_fd_sc_hd__decap_3
XTAP_TAPCELL_ROW_1_248 VGND VPWR sky130_fd_sc_hd__tapvpwrvgnd_1
X_6934_ _6965_/CLK _6934_/D VGND VGND VPWR VPWR _6934_/Q sky130_fd_sc_hd__dfxtp_2
XTAP_TAPCELL_ROW_37_656 VGND VPWR sky130_fd_sc_hd__tapvpwrvgnd_1
XFILLER_41_119 VGND VGND VPWR VPWR sky130_fd_sc_hd__fill_2
XTAP_TAPCELL_ROW_65_987 VGND VPWR sky130_fd_sc_hd__tapvpwrvgnd_1
XFILLER_50_620 VGND VGND VPWR VPWR sky130_fd_sc_hd__decap_3
XFILLER_62_480 VGND VGND VPWR VPWR sky130_fd_sc_hd__decap_3
X_6865_ clkload4/A _6865_/D VGND VGND VPWR VPWR _6865_/Q sky130_fd_sc_hd__dfxtp_2
X_6796_ _6968_/CLK _6796_/D VGND VGND VPWR VPWR _6796_/Q sky130_fd_sc_hd__dfxtp_2
XFILLER_108_416 VGND VGND VPWR VPWR sky130_fd_sc_hd__decap_3
XFILLER_41_49 VGND VGND VPWR VPWR sky130_fd_sc_hd__fill_1
XFILLER_108_427 VGND VGND VPWR VPWR sky130_fd_sc_hd__fill_2
XFILLER_108_449 VGND VGND VPWR VPWR sky130_fd_sc_hd__decap_3
X_5678_ _7345_/Q hold908/X _5697_/S VGND VGND VPWR VPWR _6689_/D sky130_fd_sc_hd__mux2_2
X_4629_ _4629_/A _4629_/B VGND VGND VPWR VPWR _4629_/Y sky130_fd_sc_hd__nor2_2
XFILLER_89_311 VGND VGND VPWR VPWR sky130_fd_sc_hd__decap_3
X_7348_ _7348_/CLK _7348_/D _6628_/Y VGND VGND VPWR VPWR _7348_/Q sky130_fd_sc_hd__dfrtp_2
XTAP_TAPCELL_ROW_9_337 VGND VPWR sky130_fd_sc_hd__tapvpwrvgnd_1
XFILLER_106_20 VGND VGND VPWR VPWR sky130_fd_sc_hd__decap_3
XFILLER_1_237 VGND VGND VPWR VPWR sky130_fd_sc_hd__decap_3
XFILLER_89_355 VGND VGND VPWR VPWR sky130_fd_sc_hd__decap_3
X_7279_ _7380_/CLK _7279_/D _6559_/Y VGND VGND VPWR VPWR _7279_/Q sky130_fd_sc_hd__dfrtp_2
Xhold584 _6896_/Q VGND VGND VPWR VPWR _6896_/D sky130_fd_sc_hd__dlygate4sd3_1
Xhold595 _6784_/Q VGND VGND VPWR VPWR _6784_/D sky130_fd_sc_hd__dlygate4sd3_1
XFILLER_103_165 VGND VGND VPWR VPWR sky130_fd_sc_hd__decap_3
XFILLER_106_53 VGND VGND VPWR VPWR sky130_fd_sc_hd__decap_3
XFILLER_49_208 VGND VGND VPWR VPWR sky130_fd_sc_hd__fill_1
XFILLER_77_517 VGND VGND VPWR VPWR sky130_fd_sc_hd__fill_2
XFILLER_89_388 VGND VGND VPWR VPWR sky130_fd_sc_hd__decap_3
XFILLER_106_97 VGND VGND VPWR VPWR sky130_fd_sc_hd__decap_3
XFILLER_85_550 VGND VGND VPWR VPWR sky130_fd_sc_hd__decap_3
XFILLER_85_561 VGND VGND VPWR VPWR sky130_fd_sc_hd__decap_3
XFILLER_85_572 VGND VGND VPWR VPWR sky130_fd_sc_hd__decap_3
XFILLER_17_116 VGND VGND VPWR VPWR sky130_fd_sc_hd__decap_3
XFILLER_18_628 VGND VGND VPWR VPWR sky130_fd_sc_hd__decap_3
XFILLER_45_414 VGND VGND VPWR VPWR sky130_fd_sc_hd__fill_1
XFILLER_45_436 VGND VGND VPWR VPWR sky130_fd_sc_hd__decap_3
XFILLER_57_274 VGND VGND VPWR VPWR sky130_fd_sc_hd__decap_3
XFILLER_72_200 VGND VGND VPWR VPWR sky130_fd_sc_hd__decap_3
XFILLER_72_233 VGND VGND VPWR VPWR sky130_fd_sc_hd__decap_3
XFILLER_32_108 VGND VGND VPWR VPWR sky130_fd_sc_hd__fill_1
XFILLER_13_322 VGND VGND VPWR VPWR sky130_fd_sc_hd__decap_3
XFILLER_25_193 VGND VGND VPWR VPWR sky130_fd_sc_hd__decap_3
XFILLER_41_620 VGND VGND VPWR VPWR sky130_fd_sc_hd__decap_3
XFILLER_53_491 VGND VGND VPWR VPWR sky130_fd_sc_hd__decap_3
XFILLER_72_299 VGND VGND VPWR VPWR sky130_fd_sc_hd__decap_3
XFILLER_13_355 VGND VGND VPWR VPWR sky130_fd_sc_hd__decap_3
XFILLER_13_366 VGND VGND VPWR VPWR sky130_fd_sc_hd__decap_3
XFILLER_40_141 VGND VGND VPWR VPWR sky130_fd_sc_hd__decap_3
XFILLER_40_174 VGND VGND VPWR VPWR sky130_fd_sc_hd__decap_3
XFILLER_9_337 VGND VGND VPWR VPWR sky130_fd_sc_hd__decap_3
XFILLER_31_60 VGND VGND VPWR VPWR sky130_fd_sc_hd__decap_3
XTAP_TAPCELL_ROW_93_1308 VGND VPWR sky130_fd_sc_hd__tapvpwrvgnd_1
XFILLER_5_576 VGND VGND VPWR VPWR sky130_fd_sc_hd__decap_3
XFILLER_0_281 VGND VGND VPWR VPWR sky130_fd_sc_hd__decap_3
XFILLER_36_436 VGND VGND VPWR VPWR sky130_fd_sc_hd__decap_3
XFILLER_48_285 VGND VGND VPWR VPWR sky130_fd_sc_hd__decap_3
XFILLER_91_520 VGND VGND VPWR VPWR sky130_fd_sc_hd__decap_3
XFILLER_36_458 VGND VGND VPWR VPWR sky130_fd_sc_hd__decap_3
XFILLER_36_469 VGND VGND VPWR VPWR sky130_fd_sc_hd__decap_3
XFILLER_91_553 VGND VGND VPWR VPWR sky130_fd_sc_hd__decap_3
XFILLER_91_564 VGND VGND VPWR VPWR sky130_fd_sc_hd__decap_3
XFILLER_63_277 VGND VGND VPWR VPWR sky130_fd_sc_hd__decap_3
XTAP_TAPCELL_ROW_102_1404 VGND VPWR sky130_fd_sc_hd__tapvpwrvgnd_1
XFILLER_16_171 VGND VGND VPWR VPWR sky130_fd_sc_hd__fill_1
XFILLER_16_182 VGND VGND VPWR VPWR sky130_fd_sc_hd__decap_3
XFILLER_32_631 VGND VGND VPWR VPWR sky130_fd_sc_hd__decap_3
Xplace288 _5660_/B VGND VGND VPWR VPWR _3887_/A2 sky130_fd_sc_hd__buf_2
Xplace277 _3881_/A2 VGND VGND VPWR VPWR _3884_/A2 sky130_fd_sc_hd__buf_2
Xplace266 _3927_/A1 VGND VGND VPWR VPWR _3682_/A sky130_fd_sc_hd__buf_2
X_3931_ _7374_/Q _4474_/A0 _3943_/S VGND VGND VPWR VPWR _7374_/D sky130_fd_sc_hd__mux2_2
XTAP_TAPCELL_ROW_62_946 VGND VPWR sky130_fd_sc_hd__tapvpwrvgnd_1
XTAP_TAPCELL_ROW_34_626 VGND VPWR sky130_fd_sc_hd__tapvpwrvgnd_1
Xplace299 _3634_/Y VGND VGND VPWR VPWR _3991_/B sky130_fd_sc_hd__buf_2
X_6650_ _6650_/A VGND VGND VPWR VPWR _6650_/Y sky130_fd_sc_hd__inv_2
X_3862_ _6923_/Q _3862_/A2 _3913_/A2 _6787_/Q VGND VGND VPWR VPWR _3862_/X sky130_fd_sc_hd__a22o_2
XFILLER_31_163 VGND VGND VPWR VPWR sky130_fd_sc_hd__decap_3
X_6581_ _6613_/A VGND VGND VPWR VPWR _6581_/Y sky130_fd_sc_hd__inv_2
X_3793_ _6756_/Q _3913_/B1 _3881_/B1 _6768_/Q VGND VGND VPWR VPWR _3793_/X sky130_fd_sc_hd__a22o_2
XTAP_TAPCELL_ROW_14_394 VGND VPWR sky130_fd_sc_hd__tapvpwrvgnd_1
XFILLER_105_408 VGND VGND VPWR VPWR sky130_fd_sc_hd__decap_3
X_7202_ _7269_/CLK _7202_/D _6482_/Y VGND VGND VPWR VPWR _7202_/Q sky130_fd_sc_hd__dfrtp_2
X_5394_ _5394_/A0 _4964_/X _5400_/S VGND VGND VPWR VPWR _7136_/D sky130_fd_sc_hd__mux2_2
X_4414_ _7240_/Q _4414_/A2 _4414_/B1 _7208_/Q VGND VGND VPWR VPWR _4414_/X sky130_fd_sc_hd__a22o_2
X_7133_ _7357_/CLK _7133_/D _6413_/Y VGND VGND VPWR VPWR _7133_/Q sky130_fd_sc_hd__dfrtp_2
X_4345_ _4343_/X _4345_/B VGND VGND VPWR VPWR _5101_/B sky130_fd_sc_hd__nand2b_2
XTAP_TAPCELL_ROW_6_307 VGND VPWR sky130_fd_sc_hd__tapvpwrvgnd_1
XFILLER_101_614 VGND VGND VPWR VPWR sky130_fd_sc_hd__fill_2
XFILLER_98_141 VGND VGND VPWR VPWR sky130_fd_sc_hd__decap_3
XFILLER_100_113 VGND VGND VPWR VPWR sky130_fd_sc_hd__decap_3
XFILLER_101_647 VGND VGND VPWR VPWR sky130_fd_sc_hd__fill_1
XFILLER_86_325 VGND VGND VPWR VPWR sky130_fd_sc_hd__decap_3
X_7064_ clkload9/A _7064_/D _6344_/Y VGND VGND VPWR VPWR _7064_/Q sky130_fd_sc_hd__dfrtp_2
XFILLER_98_185 VGND VGND VPWR VPWR sky130_fd_sc_hd__decap_3
XFILLER_67_561 VGND VGND VPWR VPWR sky130_fd_sc_hd__decap_3
XFILLER_100_179 VGND VGND VPWR VPWR sky130_fd_sc_hd__decap_3
XFILLER_27_403 VGND VGND VPWR VPWR sky130_fd_sc_hd__fill_1
XFILLER_36_27 VGND VGND VPWR VPWR sky130_fd_sc_hd__fill_1
XFILLER_54_200 VGND VGND VPWR VPWR sky130_fd_sc_hd__fill_1
XFILLER_54_211 VGND VGND VPWR VPWR sky130_fd_sc_hd__decap_3
XTAP_TAPCELL_ROW_68_1012 VGND VPWR sky130_fd_sc_hd__tapvpwrvgnd_1
XFILLER_15_609 VGND VGND VPWR VPWR sky130_fd_sc_hd__decap_3
XFILLER_54_233 VGND VGND VPWR VPWR sky130_fd_sc_hd__decap_3
XFILLER_54_288 VGND VGND VPWR VPWR sky130_fd_sc_hd__decap_3
XFILLER_82_597 VGND VGND VPWR VPWR sky130_fd_sc_hd__decap_3
XFILLER_23_620 VGND VGND VPWR VPWR sky130_fd_sc_hd__decap_3
X_6917_ clkload3/A _6917_/D VGND VGND VPWR VPWR _6917_/Q sky130_fd_sc_hd__dfxtp_2
XFILLER_22_152 VGND VGND VPWR VPWR sky130_fd_sc_hd__fill_1
X_6848_ clkload3/A _6848_/D VGND VGND VPWR VPWR _6848_/Q sky130_fd_sc_hd__dfxtp_2
XFILLER_22_163 VGND VGND VPWR VPWR sky130_fd_sc_hd__fill_1
XFILLER_10_358 VGND VGND VPWR VPWR sky130_fd_sc_hd__decap_3
X_6779_ clkload4/A _6779_/D VGND VGND VPWR VPWR _6779_/Q sky130_fd_sc_hd__dfxtp_2
XFILLER_6_318 VGND VGND VPWR VPWR sky130_fd_sc_hd__decap_3
XTAP_TAPCELL_ROW_79_1141 VGND VPWR sky130_fd_sc_hd__tapvpwrvgnd_1
XFILLER_108_279 VGND VGND VPWR VPWR sky130_fd_sc_hd__fill_1
XFILLER_104_430 VGND VGND VPWR VPWR sky130_fd_sc_hd__decap_3
XFILLER_2_557 VGND VGND VPWR VPWR sky130_fd_sc_hd__decap_3
XFILLER_89_163 VGND VGND VPWR VPWR sky130_fd_sc_hd__decap_3
XFILLER_104_485 VGND VGND VPWR VPWR sky130_fd_sc_hd__decap_3
XFILLER_77_325 VGND VGND VPWR VPWR sky130_fd_sc_hd__decap_3
XFILLER_89_196 VGND VGND VPWR VPWR sky130_fd_sc_hd__decap_3
XFILLER_45_200 VGND VGND VPWR VPWR sky130_fd_sc_hd__decap_3
XFILLER_45_244 VGND VGND VPWR VPWR sky130_fd_sc_hd__fill_2
XFILLER_73_542 VGND VGND VPWR VPWR sky130_fd_sc_hd__decap_3
XFILLER_85_391 VGND VGND VPWR VPWR sky130_fd_sc_hd__fill_1
Xhold1070 _7312_/Q VGND VGND VPWR VPWR _4534_/A0 sky130_fd_sc_hd__dlygate4sd3_1
Xhold1081 _7270_/Q VGND VGND VPWR VPWR _4865_/A0 sky130_fd_sc_hd__dlygate4sd3_1
Xhold1092 _7264_/Q VGND VGND VPWR VPWR _4965_/A0 sky130_fd_sc_hd__dlygate4sd3_1
XFILLER_73_564 VGND VGND VPWR VPWR sky130_fd_sc_hd__fill_1
XFILLER_73_586 VGND VGND VPWR VPWR sky130_fd_sc_hd__decap_3
XFILLER_93_99 VGND VGND VPWR VPWR sky130_fd_sc_hd__decap_3
XFILLER_14_631 VGND VGND VPWR VPWR sky130_fd_sc_hd__decap_3
XFILLER_26_480 VGND VGND VPWR VPWR sky130_fd_sc_hd__fill_1
XFILLER_26_82 VGND VGND VPWR VPWR sky130_fd_sc_hd__fill_2
XFILLER_60_225 VGND VGND VPWR VPWR sky130_fd_sc_hd__decap_3
XFILLER_13_185 VGND VGND VPWR VPWR sky130_fd_sc_hd__decap_3
XFILLER_9_167 VGND VGND VPWR VPWR sky130_fd_sc_hd__fill_1
XTAP_TAPCELL_ROW_11_364 VGND VPWR sky130_fd_sc_hd__tapvpwrvgnd_1
XFILLER_9_178 VGND VGND VPWR VPWR sky130_fd_sc_hd__decap_3
XFILLER_5_340 VGND VGND VPWR VPWR sky130_fd_sc_hd__decap_3
XFILLER_54_6 VGND VGND VPWR VPWR sky130_fd_sc_hd__decap_3
X_4130_ _7235_/Q _4430_/A2 _4261_/B1 _7171_/Q _4129_/X VGND VGND VPWR VPWR _4130_/X
+ sky130_fd_sc_hd__a221o_2
XFILLER_96_645 VGND VGND VPWR VPWR sky130_fd_sc_hd__decap_3
XFILLER_68_358 VGND VGND VPWR VPWR sky130_fd_sc_hd__decap_3
XFILLER_95_133 VGND VGND VPWR VPWR sky130_fd_sc_hd__decap_3
X_4061_ _7244_/Q _4414_/A2 _4416_/B1 _7180_/Q VGND VGND VPWR VPWR _4061_/X sky130_fd_sc_hd__a22o_2
XFILLER_36_200 VGND VGND VPWR VPWR sky130_fd_sc_hd__decap_3
XFILLER_36_244 VGND VGND VPWR VPWR sky130_fd_sc_hd__decap_3
XFILLER_64_553 VGND VGND VPWR VPWR sky130_fd_sc_hd__decap_3
XFILLER_76_380 VGND VGND VPWR VPWR sky130_fd_sc_hd__decap_3
XFILLER_24_406 VGND VGND VPWR VPWR sky130_fd_sc_hd__decap_3
XFILLER_51_203 VGND VGND VPWR VPWR sky130_fd_sc_hd__decap_3
XFILLER_64_575 VGND VGND VPWR VPWR sky130_fd_sc_hd__decap_3
XFILLER_91_350 VGND VGND VPWR VPWR sky130_fd_sc_hd__decap_3
XTAP_TAPCELL_ROW_47_773 VGND VPWR sky130_fd_sc_hd__tapvpwrvgnd_1
XTAP_TAPCELL_ROW_19_453 VGND VPWR sky130_fd_sc_hd__tapvpwrvgnd_1
XFILLER_51_225 VGND VGND VPWR VPWR sky130_fd_sc_hd__decap_3
XFILLER_91_383 VGND VGND VPWR VPWR sky130_fd_sc_hd__decap_3
X_4963_ _4963_/A _4963_/B VGND VGND VPWR VPWR _6994_/D sky130_fd_sc_hd__nor2_2
X_6702_ _7071_/CLK _6702_/D VGND VGND VPWR VPWR _6702_/Q sky130_fd_sc_hd__dfxtp_2
X_3914_ _3927_/A1 _3911_/X _3913_/X _3714_/X VGND VGND VPWR VPWR _3914_/X sky130_fd_sc_hd__a22o_2
XFILLER_20_601 VGND VGND VPWR VPWR sky130_fd_sc_hd__decap_3
XFILLER_20_634 VGND VGND VPWR VPWR sky130_fd_sc_hd__decap_3
XFILLER_32_461 VGND VGND VPWR VPWR sky130_fd_sc_hd__decap_3
X_6633_ _6636_/A VGND VGND VPWR VPWR _6633_/Y sky130_fd_sc_hd__inv_2
X_4894_ _4908_/A _4908_/B VGND VGND VPWR VPWR _4909_/B sky130_fd_sc_hd__and2_2
XFILLER_20_645 VGND VGND VPWR VPWR sky130_fd_sc_hd__decap_3
XFILLER_22_29 VGND VGND VPWR VPWR sky130_fd_sc_hd__fill_1
X_3845_ _3845_/A _3845_/B VGND VGND VPWR VPWR _3845_/X sky130_fd_sc_hd__or2_2
X_6564_ _6566_/A VGND VGND VPWR VPWR _6564_/Y sky130_fd_sc_hd__inv_2
X_3776_ _6727_/Q _3886_/A2 _3886_/B1 _6977_/Q VGND VGND VPWR VPWR _3776_/X sky130_fd_sc_hd__a22o_2
X_6495_ _6536_/A VGND VGND VPWR VPWR _6495_/Y sky130_fd_sc_hd__inv_2
XFILLER_59_303 VGND VGND VPWR VPWR sky130_fd_sc_hd__decap_3
Xoutput486 _3741_/B VGND VGND VPWR VPWR alu_result_out[6] sky130_fd_sc_hd__clkdlybuf4s25_1
Xoutput475 _5663_/B VGND VGND VPWR VPWR alu_result_out[25] sky130_fd_sc_hd__clkdlybuf4s25_1
Xoutput464 _5657_/D VGND VGND VPWR VPWR alu_result_out[15] sky130_fd_sc_hd__clkdlybuf4s25_1
X_5377_ _5377_/A0 _4822_/X _5388_/S VGND VGND VPWR VPWR _7144_/D sky130_fd_sc_hd__mux2_2
XTAP_TAPCELL_ROW_74_1082 VGND VPWR sky130_fd_sc_hd__tapvpwrvgnd_1
XFILLER_99_472 VGND VGND VPWR VPWR sky130_fd_sc_hd__decap_3
XFILLER_101_422 VGND VGND VPWR VPWR sky130_fd_sc_hd__decap_3
XFILLER_86_122 VGND VGND VPWR VPWR sky130_fd_sc_hd__decap_3
XFILLER_87_623 VGND VGND VPWR VPWR sky130_fd_sc_hd__decap_3
X_7116_ _7372_/CLK _7116_/D _6396_/Y VGND VGND VPWR VPWR _7116_/Q sky130_fd_sc_hd__dfrtp_2
Xoutput497 _5641_/Y VGND VGND VPWR VPWR instruction_out[17] sky130_fd_sc_hd__clkdlybuf4s25_1
X_4328_ _4362_/A _4362_/B _4362_/C VGND VGND VPWR VPWR _5057_/B sky130_fd_sc_hd__a21boi_2
XFILLER_99_494 VGND VGND VPWR VPWR sky130_fd_sc_hd__decap_3
XFILLER_101_455 VGND VGND VPWR VPWR sky130_fd_sc_hd__decap_3
XFILLER_74_306 VGND VGND VPWR VPWR sky130_fd_sc_hd__fill_2
XFILLER_86_144 VGND VGND VPWR VPWR sky130_fd_sc_hd__decap_3
XFILLER_86_155 VGND VGND VPWR VPWR sky130_fd_sc_hd__decap_3
X_7047_ _7397_/CLK _7047_/D _6327_/Y VGND VGND VPWR VPWR _7047_/Q sky130_fd_sc_hd__dfrtp_2
XFILLER_101_499 VGND VGND VPWR VPWR sky130_fd_sc_hd__decap_3
XFILLER_47_48 VGND VGND VPWR VPWR sky130_fd_sc_hd__decap_3
XFILLER_86_188 VGND VGND VPWR VPWR sky130_fd_sc_hd__decap_3
XFILLER_103_21 VGND VGND VPWR VPWR sky130_fd_sc_hd__decap_3
XFILLER_55_520 VGND VGND VPWR VPWR sky130_fd_sc_hd__decap_3
XFILLER_67_391 VGND VGND VPWR VPWR sky130_fd_sc_hd__fill_1
XFILLER_15_417 VGND VGND VPWR VPWR sky130_fd_sc_hd__fill_2
XFILLER_27_277 VGND VGND VPWR VPWR sky130_fd_sc_hd__decap_3
XFILLER_42_203 VGND VGND VPWR VPWR sky130_fd_sc_hd__decap_3
XFILLER_82_350 VGND VGND VPWR VPWR sky130_fd_sc_hd__fill_2
XFILLER_15_439 VGND VGND VPWR VPWR sky130_fd_sc_hd__decap_3
XFILLER_42_236 VGND VGND VPWR VPWR sky130_fd_sc_hd__decap_3
XFILLER_70_545 VGND VGND VPWR VPWR sky130_fd_sc_hd__fill_2
XFILLER_82_383 VGND VGND VPWR VPWR sky130_fd_sc_hd__decap_3
XFILLER_63_69 VGND VGND VPWR VPWR sky130_fd_sc_hd__decap_3
XFILLER_70_556 VGND VGND VPWR VPWR sky130_fd_sc_hd__decap_3
XFILLER_70_578 VGND VGND VPWR VPWR sky130_fd_sc_hd__decap_3
XFILLER_11_612 VGND VGND VPWR VPWR sky130_fd_sc_hd__decap_3
XFILLER_11_623 VGND VGND VPWR VPWR sky130_fd_sc_hd__decap_3
XFILLER_70_589 VGND VGND VPWR VPWR sky130_fd_sc_hd__decap_3
XFILLER_10_177 VGND VGND VPWR VPWR sky130_fd_sc_hd__decap_3
XFILLER_7_638 VGND VGND VPWR VPWR sky130_fd_sc_hd__decap_3
XFILLER_6_148 VGND VGND VPWR VPWR sky130_fd_sc_hd__decap_3
XFILLER_88_55 VGND VGND VPWR VPWR sky130_fd_sc_hd__fill_2
XFILLER_2_365 VGND VGND VPWR VPWR sky130_fd_sc_hd__decap_3
XFILLER_77_122 VGND VGND VPWR VPWR sky130_fd_sc_hd__decap_3
XFILLER_78_623 VGND VGND VPWR VPWR sky130_fd_sc_hd__fill_2
XFILLER_78_645 VGND VGND VPWR VPWR sky130_fd_sc_hd__decap_3
XFILLER_77_155 VGND VGND VPWR VPWR sky130_fd_sc_hd__decap_3
XFILLER_93_604 VGND VGND VPWR VPWR sky130_fd_sc_hd__fill_1
XFILLER_93_626 VGND VGND VPWR VPWR sky130_fd_sc_hd__decap_3
XFILLER_58_391 VGND VGND VPWR VPWR sky130_fd_sc_hd__decap_3
XFILLER_77_199 VGND VGND VPWR VPWR sky130_fd_sc_hd__decap_3
XFILLER_92_125 VGND VGND VPWR VPWR sky130_fd_sc_hd__decap_3
XFILLER_92_147 VGND VGND VPWR VPWR sky130_fd_sc_hd__decap_3
XFILLER_18_266 VGND VGND VPWR VPWR sky130_fd_sc_hd__decap_3
XFILLER_37_92 VGND VGND VPWR VPWR sky130_fd_sc_hd__decap_3
XFILLER_46_575 VGND VGND VPWR VPWR sky130_fd_sc_hd__decap_3
XFILLER_73_361 VGND VGND VPWR VPWR sky130_fd_sc_hd__decap_3
XFILLER_33_225 VGND VGND VPWR VPWR sky130_fd_sc_hd__decap_3
XFILLER_61_523 VGND VGND VPWR VPWR sky130_fd_sc_hd__decap_3
XTAP_TAPCELL_ROW_16_423 VGND VPWR sky130_fd_sc_hd__tapvpwrvgnd_1
XFILLER_33_247 VGND VGND VPWR VPWR sky130_fd_sc_hd__decap_3
XFILLER_61_556 VGND VGND VPWR VPWR sky130_fd_sc_hd__decap_3
XTAP_TAPCELL_ROW_44_743 VGND VPWR sky130_fd_sc_hd__tapvpwrvgnd_1
XFILLER_14_494 VGND VGND VPWR VPWR sky130_fd_sc_hd__decap_3
X_3630_ _3630_/A _3630_/B VGND VGND VPWR VPWR _3636_/B sky130_fd_sc_hd__and2_2
XTAP_TAPCELL_ROW_99_1369 VGND VPWR sky130_fd_sc_hd__tapvpwrvgnd_1
X_3561_ _3561_/A _6983_/Q _5668_/A VGND VGND VPWR VPWR _3561_/X sky130_fd_sc_hd__or3_2
X_5300_ _5300_/A0 _4752_/X _5310_/S VGND VGND VPWR VPWR _7180_/D sky130_fd_sc_hd__mux2_2
X_6280_ _6558_/A VGND VGND VPWR VPWR _6280_/Y sky130_fd_sc_hd__inv_2
X_3492_ _7055_/Q _3558_/B _3487_/X _3491_/X VGND VGND VPWR VPWR _4460_/B sky130_fd_sc_hd__o22a_2
XFILLER_69_612 VGND VGND VPWR VPWR sky130_fd_sc_hd__decap_3
XFILLER_69_623 VGND VGND VPWR VPWR sky130_fd_sc_hd__decap_3
XFILLER_68_144 VGND VGND VPWR VPWR sky130_fd_sc_hd__fill_1
X_5093_ _4467_/Y _3867_/X _5658_/C _5092_/X _3346_/A VGND VGND VPWR VPWR _5093_/X
+ sky130_fd_sc_hd__o32a_2
X_4113_ _7364_/Q _4261_/A2 _4112_/X _4347_/C1 VGND VGND VPWR VPWR _4113_/X sky130_fd_sc_hd__a211o_2
XFILLER_96_453 VGND VGND VPWR VPWR sky130_fd_sc_hd__fill_2
XFILLER_68_177 VGND VGND VPWR VPWR sky130_fd_sc_hd__decap_3
XFILLER_49_391 VGND VGND VPWR VPWR sky130_fd_sc_hd__fill_1
XFILLER_83_125 VGND VGND VPWR VPWR sky130_fd_sc_hd__decap_3
X_4044_ _7277_/Q _4422_/A2 _4041_/X _4043_/X VGND VGND VPWR VPWR _4044_/X sky130_fd_sc_hd__a211o_2
XFILLER_37_564 VGND VGND VPWR VPWR sky130_fd_sc_hd__decap_3
XFILLER_83_169 VGND VGND VPWR VPWR sky130_fd_sc_hd__decap_3
XFILLER_24_203 VGND VGND VPWR VPWR sky130_fd_sc_hd__decap_3
XFILLER_24_236 VGND VGND VPWR VPWR sky130_fd_sc_hd__decap_3
XFILLER_37_586 VGND VGND VPWR VPWR sky130_fd_sc_hd__decap_3
XTAP_TAPCELL_ROW_108_1487 VGND VPWR sky130_fd_sc_hd__tapvpwrvgnd_1
XTAP_TAPCELL_ROW_108_1476 VGND VPWR sky130_fd_sc_hd__tapvpwrvgnd_1
XFILLER_91_191 VGND VGND VPWR VPWR sky130_fd_sc_hd__decap_3
XFILLER_52_589 VGND VGND VPWR VPWR sky130_fd_sc_hd__fill_2
X_4946_ _4946_/A0 _4945_/X _4946_/S VGND VGND VPWR VPWR _7265_/D sky130_fd_sc_hd__mux2_2
X_4877_ _4799_/A _5663_/C _3753_/X _3346_/A VGND VGND VPWR VPWR _4877_/X sky130_fd_sc_hd__o211a_2
XFILLER_20_475 VGND VGND VPWR VPWR sky130_fd_sc_hd__fill_1
X_6616_ _6616_/A VGND VGND VPWR VPWR _6616_/Y sky130_fd_sc_hd__inv_2
X_3828_ _6926_/Q _3912_/A2 _3889_/A2 _6790_/Q _3827_/X VGND VGND VPWR VPWR _3828_/X
+ sky130_fd_sc_hd__a221o_2
X_6547_ _6650_/A VGND VGND VPWR VPWR _6547_/Y sky130_fd_sc_hd__inv_2
XFILLER_4_619 VGND VGND VPWR VPWR sky130_fd_sc_hd__decap_3
X_3759_ _6797_/Q _3824_/B1 _3883_/B1 _6885_/Q VGND VGND VPWR VPWR _3759_/X sky130_fd_sc_hd__a22o_2
XTAP_TAPCELL_ROW_76_1111 VGND VPWR sky130_fd_sc_hd__tapvpwrvgnd_1
X_6478_ _6669_/A VGND VGND VPWR VPWR _6478_/Y sky130_fd_sc_hd__inv_2
X_5429_ _5429_/A0 _4470_/X _5429_/S VGND VGND VPWR VPWR _7119_/D sky130_fd_sc_hd__mux2_2
XFILLER_75_604 VGND VGND VPWR VPWR sky130_fd_sc_hd__decap_3
XFILLER_101_252 VGND VGND VPWR VPWR sky130_fd_sc_hd__decap_3
XFILLER_59_188 VGND VGND VPWR VPWR sky130_fd_sc_hd__decap_3
XFILLER_101_296 VGND VGND VPWR VPWR sky130_fd_sc_hd__decap_3
XFILLER_74_136 VGND VGND VPWR VPWR sky130_fd_sc_hd__decap_3
XFILLER_74_147 VGND VGND VPWR VPWR sky130_fd_sc_hd__decap_3
XFILLER_90_607 VGND VGND VPWR VPWR sky130_fd_sc_hd__fill_2
XTAP_TAPCELL_ROW_87_1240 VGND VPWR sky130_fd_sc_hd__tapvpwrvgnd_1
XFILLER_15_225 VGND VGND VPWR VPWR sky130_fd_sc_hd__decap_3
XFILLER_28_586 VGND VGND VPWR VPWR sky130_fd_sc_hd__fill_2
XFILLER_15_236 VGND VGND VPWR VPWR sky130_fd_sc_hd__decap_3
XFILLER_15_269 VGND VGND VPWR VPWR sky130_fd_sc_hd__decap_3
XFILLER_43_567 VGND VGND VPWR VPWR sky130_fd_sc_hd__decap_3
XFILLER_70_331 VGND VGND VPWR VPWR sky130_fd_sc_hd__decap_3
XFILLER_70_353 VGND VGND VPWR VPWR sky130_fd_sc_hd__decap_3
XFILLER_30_206 VGND VGND VPWR VPWR sky130_fd_sc_hd__decap_3
XFILLER_70_386 VGND VGND VPWR VPWR sky130_fd_sc_hd__decap_3
XTAP_TAPCELL_ROW_41_702 VGND VPWR sky130_fd_sc_hd__tapvpwrvgnd_1
XFILLER_11_420 VGND VGND VPWR VPWR sky130_fd_sc_hd__decap_3
XFILLER_11_442 VGND VGND VPWR VPWR sky130_fd_sc_hd__decap_3
XFILLER_11_464 VGND VGND VPWR VPWR sky130_fd_sc_hd__decap_3
XFILLER_7_402 VGND VGND VPWR VPWR sky130_fd_sc_hd__fill_1
XFILLER_7_424 VGND VGND VPWR VPWR sky130_fd_sc_hd__fill_2
XTAP_TAPCELL_ROW_21_481 VGND VPWR sky130_fd_sc_hd__tapvpwrvgnd_1
XFILLER_99_54 VGND VGND VPWR VPWR sky130_fd_sc_hd__fill_2
XFILLER_99_98 VGND VGND VPWR VPWR sky130_fd_sc_hd__decap_3
XFILLER_3_641 VGND VGND VPWR VPWR sky130_fd_sc_hd__decap_3
XFILLER_97_206 VGND VGND VPWR VPWR sky130_fd_sc_hd__decap_3
XFILLER_2_162 VGND VGND VPWR VPWR sky130_fd_sc_hd__decap_3
XFILLER_97_228 VGND VGND VPWR VPWR sky130_fd_sc_hd__decap_3
XFILLER_38_328 VGND VGND VPWR VPWR sky130_fd_sc_hd__decap_3
XFILLER_66_637 VGND VGND VPWR VPWR sky130_fd_sc_hd__decap_3
XFILLER_78_475 VGND VGND VPWR VPWR sky130_fd_sc_hd__fill_1
XTAP_TAPCELL_ROW_49_802 VGND VPWR sky130_fd_sc_hd__tapvpwrvgnd_1
XFILLER_17_6 VGND VGND VPWR VPWR sky130_fd_sc_hd__decap_3
XFILLER_48_91 VGND VGND VPWR VPWR sky130_fd_sc_hd__fill_1
XFILLER_65_125 VGND VGND VPWR VPWR sky130_fd_sc_hd__decap_3
XFILLER_65_136 VGND VGND VPWR VPWR sky130_fd_sc_hd__decap_3
Xsingle_cycle_cpu_576 VGND VGND VPWR VPWR single_cycle_cpu_576/HI instruction_out[31]
+ sky130_fd_sc_hd__conb_1
XFILLER_65_169 VGND VGND VPWR VPWR sky130_fd_sc_hd__decap_3
XFILLER_19_597 VGND VGND VPWR VPWR sky130_fd_sc_hd__decap_3
XTAP_TAPCELL_ROW_57_890 VGND VPWR sky130_fd_sc_hd__tapvpwrvgnd_1
XTAP_TAPCELL_ROW_29_570 VGND VPWR sky130_fd_sc_hd__tapvpwrvgnd_1
XFILLER_34_545 VGND VGND VPWR VPWR sky130_fd_sc_hd__fill_1
XFILLER_34_567 VGND VGND VPWR VPWR sky130_fd_sc_hd__decap_3
XFILLER_61_331 VGND VGND VPWR VPWR sky130_fd_sc_hd__decap_3
X_4800_ _7002_/Q _4826_/A _7003_/Q VGND VGND VPWR VPWR _4801_/B sky130_fd_sc_hd__a21oi_2
XFILLER_21_228 VGND VGND VPWR VPWR sky130_fd_sc_hd__decap_3
XFILLER_34_589 VGND VGND VPWR VPWR sky130_fd_sc_hd__fill_1
XFILLER_61_364 VGND VGND VPWR VPWR sky130_fd_sc_hd__decap_3
XFILLER_14_280 VGND VGND VPWR VPWR sky130_fd_sc_hd__decap_3
X_4731_ _4731_/A _4731_/B VGND VGND VPWR VPWR _7007_/D sky130_fd_sc_hd__and2_2
X_4662_ _4969_/B _4457_/X _4660_/X _4811_/C _4040_/Y VGND VGND VPWR VPWR _4662_/Y
+ sky130_fd_sc_hd__a221oi_2
XFILLER_9_74 VGND VGND VPWR VPWR sky130_fd_sc_hd__fill_1
X_6401_ _6635_/A VGND VGND VPWR VPWR _6401_/Y sky130_fd_sc_hd__inv_2
X_3613_ _3603_/Y _3606_/X _3612_/X VGND VGND VPWR VPWR _3614_/B sky130_fd_sc_hd__a21oi_2
X_7381_ _7382_/CLK _7381_/D _6661_/Y VGND VGND VPWR VPWR _7381_/Q sky130_fd_sc_hd__dfrtp_2
Xhold903 _6702_/Q VGND VGND VPWR VPWR hold903/X sky130_fd_sc_hd__dlygate4sd3_1
X_4593_ _4593_/A _4595_/B VGND VGND VPWR VPWR _7284_/D sky130_fd_sc_hd__and2_2
Xhold914 _6688_/Q VGND VGND VPWR VPWR hold914/X sky130_fd_sc_hd__dlygate4sd3_1
Xhold925 _7023_/Q VGND VGND VPWR VPWR _5609_/A sky130_fd_sc_hd__dlygate4sd3_1
Xhold936 _7032_/Q VGND VGND VPWR VPWR _5591_/A sky130_fd_sc_hd__dlygate4sd3_1
X_6332_ _6686_/A VGND VGND VPWR VPWR _6332_/Y sky130_fd_sc_hd__inv_2
X_3544_ _3544_/A _3544_/B VGND VGND VPWR VPWR _3635_/A sky130_fd_sc_hd__nor2_2
Xhold969 _7392_/Q VGND VGND VPWR VPWR hold969/X sky130_fd_sc_hd__dlygate4sd3_1
Xhold958 _7030_/Q VGND VGND VPWR VPWR _5595_/A sky130_fd_sc_hd__dlygate4sd3_1
Xhold947 _7387_/Q VGND VGND VPWR VPWR hold947/X sky130_fd_sc_hd__dlygate4sd3_1
X_6263_ _6463_/A VGND VGND VPWR VPWR _6263_/Y sky130_fd_sc_hd__inv_2
X_3475_ _7248_/Q _4260_/A2 _3472_/X _3474_/X VGND VGND VPWR VPWR _3475_/Y sky130_fd_sc_hd__a211oi_2
XFILLER_103_528 VGND VGND VPWR VPWR sky130_fd_sc_hd__decap_3
XFILLER_88_217 VGND VGND VPWR VPWR sky130_fd_sc_hd__decap_3
XFILLER_88_239 VGND VGND VPWR VPWR sky130_fd_sc_hd__decap_3
XFILLER_69_442 VGND VGND VPWR VPWR sky130_fd_sc_hd__decap_3
XTAP_TAPCELL_ROW_71_1052 VGND VPWR sky130_fd_sc_hd__tapvpwrvgnd_1
XFILLER_29_306 VGND VGND VPWR VPWR sky130_fd_sc_hd__decap_3
XFILLER_29_317 VGND VGND VPWR VPWR sky130_fd_sc_hd__decap_3
XFILLER_57_615 VGND VGND VPWR VPWR sky130_fd_sc_hd__fill_1
XFILLER_57_626 VGND VGND VPWR VPWR sky130_fd_sc_hd__decap_3
XFILLER_69_486 VGND VGND VPWR VPWR sky130_fd_sc_hd__fill_2
X_5145_ _5145_/A _3500_/Y VGND VGND VPWR VPWR _5145_/X sky130_fd_sc_hd__or2b_2
XFILLER_56_114 VGND VGND VPWR VPWR sky130_fd_sc_hd__decap_3
XFILLER_69_497 VGND VGND VPWR VPWR sky130_fd_sc_hd__decap_3
XFILLER_25_501 VGND VGND VPWR VPWR sky130_fd_sc_hd__decap_3
XFILLER_44_309 VGND VGND VPWR VPWR sky130_fd_sc_hd__fill_1
XFILLER_84_467 VGND VGND VPWR VPWR sky130_fd_sc_hd__decap_3
XFILLER_44_49 VGND VGND VPWR VPWR sky130_fd_sc_hd__decap_3
XFILLER_80_640 VGND VGND VPWR VPWR sky130_fd_sc_hd__decap_3
XFILLER_100_11 VGND VGND VPWR VPWR sky130_fd_sc_hd__decap_3
XFILLER_12_206 VGND VGND VPWR VPWR sky130_fd_sc_hd__decap_3
XFILLER_40_526 VGND VGND VPWR VPWR sky130_fd_sc_hd__decap_3
XFILLER_40_548 VGND VGND VPWR VPWR sky130_fd_sc_hd__fill_2
X_4929_ _4908_/B _4928_/Y _4983_/A VGND VGND VPWR VPWR _4929_/Y sky130_fd_sc_hd__o21ai_2
XTAP_TAPCELL_ROW_82_1181 VGND VPWR sky130_fd_sc_hd__tapvpwrvgnd_1
XFILLER_106_344 VGND VGND VPWR VPWR sky130_fd_sc_hd__fill_1
XFILLER_69_57 VGND VGND VPWR VPWR sky130_fd_sc_hd__decap_3
XFILLER_0_611 VGND VGND VPWR VPWR sky130_fd_sc_hd__decap_3
XFILLER_106_377 VGND VGND VPWR VPWR sky130_fd_sc_hd__decap_3
XFILLER_106_399 VGND VGND VPWR VPWR sky130_fd_sc_hd__decap_3
XFILLER_79_217 VGND VGND VPWR VPWR sky130_fd_sc_hd__decap_3
XFILLER_102_561 VGND VGND VPWR VPWR sky130_fd_sc_hd__decap_3
XFILLER_47_103 VGND VGND VPWR VPWR sky130_fd_sc_hd__decap_3
XFILLER_48_637 VGND VGND VPWR VPWR sky130_fd_sc_hd__decap_3
XFILLER_75_423 VGND VGND VPWR VPWR sky130_fd_sc_hd__fill_1
XFILLER_47_158 VGND VGND VPWR VPWR sky130_fd_sc_hd__decap_3
XFILLER_47_169 VGND VGND VPWR VPWR sky130_fd_sc_hd__decap_3
XFILLER_63_607 VGND VGND VPWR VPWR sky130_fd_sc_hd__decap_3
XFILLER_63_629 VGND VGND VPWR VPWR sky130_fd_sc_hd__decap_3
XFILLER_75_478 VGND VGND VPWR VPWR sky130_fd_sc_hd__decap_3
XFILLER_18_83 VGND VGND VPWR VPWR sky130_fd_sc_hd__fill_1
XFILLER_28_383 VGND VGND VPWR VPWR sky130_fd_sc_hd__decap_3
XFILLER_90_426 VGND VGND VPWR VPWR sky130_fd_sc_hd__decap_3
XFILLER_16_589 VGND VGND VPWR VPWR sky130_fd_sc_hd__decap_3
XTAP_TAPCELL_ROW_54_860 VGND VPWR sky130_fd_sc_hd__tapvpwrvgnd_1
XFILLER_34_82 VGND VGND VPWR VPWR sky130_fd_sc_hd__fill_2
XFILLER_11_272 VGND VGND VPWR VPWR sky130_fd_sc_hd__decap_3
XFILLER_7_243 VGND VGND VPWR VPWR sky130_fd_sc_hd__decap_3
XTAP_TAPCELL_ROW_96_1339 VGND VPWR sky130_fd_sc_hd__tapvpwrvgnd_1
XFILLER_7_276 VGND VGND VPWR VPWR sky130_fd_sc_hd__decap_3
XFILLER_98_548 VGND VGND VPWR VPWR sky130_fd_sc_hd__fill_1
XFILLER_39_615 VGND VGND VPWR VPWR sky130_fd_sc_hd__fill_1
XFILLER_39_626 VGND VGND VPWR VPWR sky130_fd_sc_hd__decap_3
XFILLER_15_3 VGND VGND VPWR VPWR sky130_fd_sc_hd__decap_3
XFILLER_38_136 VGND VGND VPWR VPWR sky130_fd_sc_hd__decap_3
XFILLER_26_309 VGND VGND VPWR VPWR sky130_fd_sc_hd__decap_3
XFILLER_38_147 VGND VGND VPWR VPWR sky130_fd_sc_hd__decap_3
XFILLER_54_629 VGND VGND VPWR VPWR sky130_fd_sc_hd__decap_3
X_6950_ _6974_/CLK _6950_/D VGND VGND VPWR VPWR _6950_/Q sky130_fd_sc_hd__dfxtp_2
XFILLER_53_128 VGND VGND VPWR VPWR sky130_fd_sc_hd__fill_2
XFILLER_81_415 VGND VGND VPWR VPWR sky130_fd_sc_hd__decap_3
XFILLER_93_297 VGND VGND VPWR VPWR sky130_fd_sc_hd__fill_1
XFILLER_46_191 VGND VGND VPWR VPWR sky130_fd_sc_hd__decap_3
X_6881_ _6963_/CLK _6881_/D VGND VGND VPWR VPWR _6881_/Q sky130_fd_sc_hd__dfxtp_2
XTAP_TAPCELL_ROW_105_1446 VGND VPWR sky130_fd_sc_hd__tapvpwrvgnd_1
XFILLER_34_353 VGND VGND VPWR VPWR sky130_fd_sc_hd__decap_3
XFILLER_61_161 VGND VGND VPWR VPWR sky130_fd_sc_hd__decap_3
XFILLER_61_172 VGND VGND VPWR VPWR sky130_fd_sc_hd__decap_3
XFILLER_61_194 VGND VGND VPWR VPWR sky130_fd_sc_hd__decap_3
XFILLER_30_592 VGND VGND VPWR VPWR sky130_fd_sc_hd__decap_3
XTAP_TAPCELL_ROW_32_598 VGND VPWR sky130_fd_sc_hd__tapvpwrvgnd_1
X_4645_ _4633_/X _4903_/B _4644_/X _4096_/A VGND VGND VPWR VPWR _4646_/B sky130_fd_sc_hd__o211a_2
X_7364_ _7364_/CLK _7364_/D _6644_/Y VGND VGND VPWR VPWR _7364_/Q sky130_fd_sc_hd__dfrtp_2
Xhold700 _6759_/Q VGND VGND VPWR VPWR _6759_/D sky130_fd_sc_hd__dlygate4sd3_1
Xhold711 _6934_/Q VGND VGND VPWR VPWR _6934_/D sky130_fd_sc_hd__dlygate4sd3_1
Xhold722 _6973_/Q VGND VGND VPWR VPWR _6973_/D sky130_fd_sc_hd__dlygate4sd3_1
Xhold733 _6800_/Q VGND VGND VPWR VPWR _6800_/D sky130_fd_sc_hd__dlygate4sd3_1
Xhold744 _6948_/Q VGND VGND VPWR VPWR _6948_/D sky130_fd_sc_hd__dlygate4sd3_1
Xhold755 _6791_/Q VGND VGND VPWR VPWR _6791_/D sky130_fd_sc_hd__dlygate4sd3_1
X_6315_ _6463_/A VGND VGND VPWR VPWR _6315_/Y sky130_fd_sc_hd__inv_2
X_3527_ _3527_/A _3427_/B VGND VGND VPWR VPWR _4614_/A sky130_fd_sc_hd__nor2b_2
XFILLER_103_314 VGND VGND VPWR VPWR sky130_fd_sc_hd__decap_3
XFILLER_89_548 VGND VGND VPWR VPWR sky130_fd_sc_hd__decap_3
X_7295_ _7364_/CLK _7295_/D _6575_/Y VGND VGND VPWR VPWR _7295_/Q sky130_fd_sc_hd__dfrtp_2
Xhold766 _6746_/Q VGND VGND VPWR VPWR _6746_/D sky130_fd_sc_hd__dlygate4sd3_1
Xhold777 _6940_/Q VGND VGND VPWR VPWR _6940_/D sky130_fd_sc_hd__dlygate4sd3_1
Xhold788 _6866_/Q VGND VGND VPWR VPWR _6866_/D sky130_fd_sc_hd__dlygate4sd3_1
Xhold799 _6941_/Q VGND VGND VPWR VPWR _6941_/D sky130_fd_sc_hd__dlygate4sd3_1
X_3458_ _3544_/A _3506_/B VGND VGND VPWR VPWR _3458_/Y sky130_fd_sc_hd__nor2_2
XFILLER_69_250 VGND VGND VPWR VPWR sky130_fd_sc_hd__decap_3
XFILLER_76_209 VGND VGND VPWR VPWR sky130_fd_sc_hd__decap_3
X_3389_ _7347_/Q _4285_/B1 _3384_/X _4248_/A VGND VGND VPWR VPWR _3389_/X sky130_fd_sc_hd__a211o_2
XFILLER_97_570 VGND VGND VPWR VPWR sky130_fd_sc_hd__decap_3
XFILLER_29_125 VGND VGND VPWR VPWR sky130_fd_sc_hd__decap_3
X_5128_ _3733_/C _3904_/Y _4677_/B VGND VGND VPWR VPWR _5128_/Y sky130_fd_sc_hd__a21oi_2
XFILLER_29_169 VGND VGND VPWR VPWR sky130_fd_sc_hd__decap_3
XFILLER_84_253 VGND VGND VPWR VPWR sky130_fd_sc_hd__decap_3
XTAP_TAPCELL_ROW_4_279 VGND VPWR sky130_fd_sc_hd__tapvpwrvgnd_1
XFILLER_45_629 VGND VGND VPWR VPWR sky130_fd_sc_hd__decap_3
XFILLER_84_275 VGND VGND VPWR VPWR sky130_fd_sc_hd__fill_2
X_5059_ _4832_/A _3859_/X _5662_/B VGND VGND VPWR VPWR _5059_/X sky130_fd_sc_hd__a21o_2
XFILLER_25_331 VGND VGND VPWR VPWR sky130_fd_sc_hd__decap_3
XFILLER_37_180 VGND VGND VPWR VPWR sky130_fd_sc_hd__decap_3
XFILLER_25_353 VGND VGND VPWR VPWR sky130_fd_sc_hd__decap_3
XFILLER_40_312 VGND VGND VPWR VPWR sky130_fd_sc_hd__decap_3
XFILLER_52_183 VGND VGND VPWR VPWR sky130_fd_sc_hd__decap_3
XFILLER_71_25 VGND VGND VPWR VPWR sky130_fd_sc_hd__fill_2
XFILLER_71_47 VGND VGND VPWR VPWR sky130_fd_sc_hd__fill_1
XFILLER_9_508 VGND VGND VPWR VPWR sky130_fd_sc_hd__fill_2
XFILLER_107_620 VGND VGND VPWR VPWR sky130_fd_sc_hd__decap_3
XFILLER_106_141 VGND VGND VPWR VPWR sky130_fd_sc_hd__fill_2
XFILLER_4_235 VGND VGND VPWR VPWR sky130_fd_sc_hd__decap_3
XFILLER_48_401 VGND VGND VPWR VPWR sky130_fd_sc_hd__decap_3
XFILLER_96_77 VGND VGND VPWR VPWR sky130_fd_sc_hd__decap_3
XFILLER_95_529 VGND VGND VPWR VPWR sky130_fd_sc_hd__decap_3
XFILLER_75_220 VGND VGND VPWR VPWR sky130_fd_sc_hd__decap_3
XFILLER_75_253 VGND VGND VPWR VPWR sky130_fd_sc_hd__decap_3
XFILLER_36_629 VGND VGND VPWR VPWR sky130_fd_sc_hd__decap_3
Xplace404 _4532_/S VGND VGND VPWR VPWR _4495_/S sky130_fd_sc_hd__buf_2
XFILLER_35_139 VGND VGND VPWR VPWR sky130_fd_sc_hd__decap_3
XFILLER_44_640 VGND VGND VPWR VPWR sky130_fd_sc_hd__decap_3
XFILLER_90_256 VGND VGND VPWR VPWR sky130_fd_sc_hd__decap_3
Xplace415 _3376_/Y VGND VGND VPWR VPWR _5161_/A sky130_fd_sc_hd__buf_2
Xplace426 _4471_/S VGND VGND VPWR VPWR _3994_/S sky130_fd_sc_hd__buf_2
Xplace437 _5581_/S VGND VGND VPWR VPWR _5595_/B sky130_fd_sc_hd__buf_2
XFILLER_16_353 VGND VGND VPWR VPWR sky130_fd_sc_hd__decap_3
XFILLER_71_470 VGND VGND VPWR VPWR sky130_fd_sc_hd__decap_3
Xplace448 _6982_/Q VGND VGND VPWR VPWR _3340_/A sky130_fd_sc_hd__buf_2
XFILLER_31_334 VGND VGND VPWR VPWR sky130_fd_sc_hd__fill_2
XFILLER_43_183 VGND VGND VPWR VPWR sky130_fd_sc_hd__decap_3
XFILLER_84_6 VGND VGND VPWR VPWR sky130_fd_sc_hd__fill_2
XFILLER_12_570 VGND VGND VPWR VPWR sky130_fd_sc_hd__decap_3
XFILLER_12_592 VGND VGND VPWR VPWR sky130_fd_sc_hd__decap_3
XTAP_TAPCELL_ROW_100_1387 VGND VPWR sky130_fd_sc_hd__tapvpwrvgnd_1
XANTENNA_2 clk VGND VGND VPWR VPWR sky130_fd_sc_hd__diode_2
X_4430_ _7239_/Q _4430_/A2 _4459_/C1 _7175_/Q _4429_/X VGND VGND VPWR VPWR _4430_/X
+ sky130_fd_sc_hd__a221o_2
X_4361_ _4361_/A _4619_/B _5101_/B _5073_/A VGND VGND VPWR VPWR _4361_/X sky130_fd_sc_hd__and4_2
XFILLER_98_323 VGND VGND VPWR VPWR sky130_fd_sc_hd__decap_3
XFILLER_98_312 VGND VGND VPWR VPWR sky130_fd_sc_hd__fill_2
X_7080_ _7406_/CLK _7080_/D _6360_/Y VGND VGND VPWR VPWR _7080_/Q sky130_fd_sc_hd__dfrtp_2
X_4292_ _4292_/A _4292_/B _4292_/C VGND VGND VPWR VPWR _4292_/X sky130_fd_sc_hd__and3_2
X_3312_ _5129_/A _4467_/A _3519_/B _3310_/Y _5671_/A VGND VGND VPWR VPWR _5646_/A
+ sky130_fd_sc_hd__a311o_2
XFILLER_58_209 VGND VGND VPWR VPWR sky130_fd_sc_hd__fill_1
XFILLER_79_592 VGND VGND VPWR VPWR sky130_fd_sc_hd__decap_3
XFILLER_39_478 VGND VGND VPWR VPWR sky130_fd_sc_hd__decap_3
XFILLER_26_117 VGND VGND VPWR VPWR sky130_fd_sc_hd__decap_3
XFILLER_27_629 VGND VGND VPWR VPWR sky130_fd_sc_hd__decap_3
XFILLER_66_264 VGND VGND VPWR VPWR sky130_fd_sc_hd__decap_3
XFILLER_94_595 VGND VGND VPWR VPWR sky130_fd_sc_hd__decap_3
XTAP_TAPCELL_ROW_1_249 VGND VPWR sky130_fd_sc_hd__tapvpwrvgnd_1
XFILLER_81_223 VGND VGND VPWR VPWR sky130_fd_sc_hd__fill_1
XFILLER_81_234 VGND VGND VPWR VPWR sky130_fd_sc_hd__decap_3
X_6933_ _6965_/CLK _6933_/D VGND VGND VPWR VPWR _6933_/Q sky130_fd_sc_hd__dfxtp_2
XTAP_TAPCELL_ROW_37_657 VGND VPWR sky130_fd_sc_hd__tapvpwrvgnd_1
XFILLER_34_150 VGND VGND VPWR VPWR sky130_fd_sc_hd__decap_3
X_6864_ _6943_/CLK _6864_/D VGND VGND VPWR VPWR _6864_/Q sky130_fd_sc_hd__dfxtp_2
XTAP_TAPCELL_ROW_65_977 VGND VPWR sky130_fd_sc_hd__tapvpwrvgnd_1
XFILLER_22_312 VGND VGND VPWR VPWR sky130_fd_sc_hd__decap_3
XFILLER_50_632 VGND VGND VPWR VPWR sky130_fd_sc_hd__decap_3
X_6795_ _7071_/CLK _6795_/D VGND VGND VPWR VPWR _6795_/Q sky130_fd_sc_hd__dfxtp_2
X_4628_ _4628_/A VGND VGND VPWR VPWR _4629_/A sky130_fd_sc_hd__inv_2
XFILLER_104_623 VGND VGND VPWR VPWR sky130_fd_sc_hd__decap_3
XFILLER_89_301 VGND VGND VPWR VPWR sky130_fd_sc_hd__fill_2
XFILLER_89_323 VGND VGND VPWR VPWR sky130_fd_sc_hd__fill_1
X_7347_ _7350_/CLK _7347_/D _6627_/Y VGND VGND VPWR VPWR _7347_/Q sky130_fd_sc_hd__dfrtp_2
X_4559_ _4559_/A _4573_/B VGND VGND VPWR VPWR _7301_/D sky130_fd_sc_hd__and2_2
XTAP_TAPCELL_ROW_9_338 VGND VPWR sky130_fd_sc_hd__tapvpwrvgnd_1
XFILLER_103_111 VGND VGND VPWR VPWR sky130_fd_sc_hd__fill_1
XFILLER_103_122 VGND VGND VPWR VPWR sky130_fd_sc_hd__decap_3
XFILLER_104_645 VGND VGND VPWR VPWR sky130_fd_sc_hd__decap_3
XFILLER_1_249 VGND VGND VPWR VPWR sky130_fd_sc_hd__decap_3
X_7278_ _7372_/CLK _7278_/D _6558_/Y VGND VGND VPWR VPWR _7278_/Q sky130_fd_sc_hd__dfrtp_2
Xhold585 _6922_/Q VGND VGND VPWR VPWR _6922_/D sky130_fd_sc_hd__dlygate4sd3_1
Xhold596 _6955_/Q VGND VGND VPWR VPWR _6955_/D sky130_fd_sc_hd__dlygate4sd3_1
XFILLER_106_32 VGND VGND VPWR VPWR sky130_fd_sc_hd__decap_3
XFILLER_103_188 VGND VGND VPWR VPWR sky130_fd_sc_hd__decap_3
XFILLER_106_65 VGND VGND VPWR VPWR sky130_fd_sc_hd__decap_3
XFILLER_66_25 VGND VGND VPWR VPWR sky130_fd_sc_hd__decap_3
XFILLER_18_607 VGND VGND VPWR VPWR sky130_fd_sc_hd__decap_3
XFILLER_57_231 VGND VGND VPWR VPWR sky130_fd_sc_hd__decap_3
XFILLER_66_58 VGND VGND VPWR VPWR sky130_fd_sc_hd__fill_1
XFILLER_17_106 VGND VGND VPWR VPWR sky130_fd_sc_hd__decap_3
XFILLER_45_426 VGND VGND VPWR VPWR sky130_fd_sc_hd__fill_2
XFILLER_72_212 VGND VGND VPWR VPWR sky130_fd_sc_hd__fill_2
XFILLER_85_584 VGND VGND VPWR VPWR sky130_fd_sc_hd__decap_3
XFILLER_45_459 VGND VGND VPWR VPWR sky130_fd_sc_hd__decap_3
XFILLER_60_407 VGND VGND VPWR VPWR sky130_fd_sc_hd__decap_3
XFILLER_72_278 VGND VGND VPWR VPWR sky130_fd_sc_hd__decap_3
XFILLER_82_35 VGND VGND VPWR VPWR sky130_fd_sc_hd__fill_1
XFILLER_25_172 VGND VGND VPWR VPWR sky130_fd_sc_hd__decap_3
XFILLER_41_632 VGND VGND VPWR VPWR sky130_fd_sc_hd__decap_3
XFILLER_13_378 VGND VGND VPWR VPWR sky130_fd_sc_hd__fill_2
XFILLER_15_95 VGND VGND VPWR VPWR sky130_fd_sc_hd__fill_2
XFILLER_40_164 VGND VGND VPWR VPWR sky130_fd_sc_hd__fill_2
XFILLER_40_197 VGND VGND VPWR VPWR sky130_fd_sc_hd__decap_3
XTAP_TAPCELL_ROW_93_1309 VGND VPWR sky130_fd_sc_hd__tapvpwrvgnd_1
XFILLER_107_461 VGND VGND VPWR VPWR sky130_fd_sc_hd__fill_1
XFILLER_5_588 VGND VGND VPWR VPWR sky130_fd_sc_hd__decap_3
XFILLER_95_337 VGND VGND VPWR VPWR sky130_fd_sc_hd__decap_3
XFILLER_0_293 VGND VGND VPWR VPWR sky130_fd_sc_hd__decap_3
XFILLER_48_253 VGND VGND VPWR VPWR sky130_fd_sc_hd__decap_3
XFILLER_36_415 VGND VGND VPWR VPWR sky130_fd_sc_hd__decap_3
XFILLER_63_234 VGND VGND VPWR VPWR sky130_fd_sc_hd__decap_3
XFILLER_91_532 VGND VGND VPWR VPWR sky130_fd_sc_hd__decap_3
XFILLER_51_407 VGND VGND VPWR VPWR sky130_fd_sc_hd__decap_3
XFILLER_32_610 VGND VGND VPWR VPWR sky130_fd_sc_hd__decap_3
XFILLER_44_470 VGND VGND VPWR VPWR sky130_fd_sc_hd__decap_3
XFILLER_44_492 VGND VGND VPWR VPWR sky130_fd_sc_hd__decap_3
Xplace289 _3656_/Y VGND VGND VPWR VPWR _5660_/B sky130_fd_sc_hd__buf_2
Xplace278 _3912_/A2 VGND VGND VPWR VPWR _3881_/A2 sky130_fd_sc_hd__buf_2
Xplace267 _5660_/A VGND VGND VPWR VPWR _3927_/A1 sky130_fd_sc_hd__buf_2
XTAP_TAPCELL_ROW_62_947 VGND VPWR sky130_fd_sc_hd__tapvpwrvgnd_1
XTAP_TAPCELL_ROW_34_627 VGND VPWR sky130_fd_sc_hd__tapvpwrvgnd_1
XTAP_TAPCELL_ROW_102_1405 VGND VPWR sky130_fd_sc_hd__tapvpwrvgnd_1
XFILLER_16_194 VGND VGND VPWR VPWR sky130_fd_sc_hd__fill_2
XFILLER_31_142 VGND VGND VPWR VPWR sky130_fd_sc_hd__decap_3
XFILLER_32_643 VGND VGND VPWR VPWR sky130_fd_sc_hd__fill_1
XFILLER_82_3 VGND VGND VPWR VPWR sky130_fd_sc_hd__decap_3
X_6580_ _6612_/A VGND VGND VPWR VPWR _6580_/Y sky130_fd_sc_hd__inv_2
X_5600_ _5600_/A _5634_/B VGND VGND VPWR VPWR _7027_/D sky130_fd_sc_hd__and2_2
X_3792_ hold969/X _3857_/A2 _4961_/A VGND VGND VPWR VPWR _7392_/D sky130_fd_sc_hd__a21o_2
XTAP_TAPCELL_ROW_14_395 VGND VPWR sky130_fd_sc_hd__tapvpwrvgnd_1
XFILLER_8_382 VGND VGND VPWR VPWR sky130_fd_sc_hd__decap_3
X_7201_ _7269_/CLK _7201_/D _6481_/Y VGND VGND VPWR VPWR _7201_/Q sky130_fd_sc_hd__dfrtp_2
X_4413_ _4413_/A VGND VGND VPWR VPWR _4787_/A sky130_fd_sc_hd__inv_2
XFILLER_99_610 VGND VGND VPWR VPWR sky130_fd_sc_hd__decap_3
X_7132_ _7352_/CLK _7132_/D _6412_/Y VGND VGND VPWR VPWR _7132_/Q sky130_fd_sc_hd__dfrtp_2
X_4344_ _4365_/A _4365_/B _4365_/C VGND VGND VPWR VPWR _4345_/B sky130_fd_sc_hd__a21bo_2
XTAP_TAPCELL_ROW_6_308 VGND VPWR sky130_fd_sc_hd__tapvpwrvgnd_1
XFILLER_99_632 VGND VGND VPWR VPWR sky130_fd_sc_hd__decap_3
XFILLER_86_304 VGND VGND VPWR VPWR sky130_fd_sc_hd__decap_3
X_7063_ _7383_/CLK _7063_/D _6343_/Y VGND VGND VPWR VPWR _7063_/Q sky130_fd_sc_hd__dfrtp_2
XFILLER_100_125 VGND VGND VPWR VPWR sky130_fd_sc_hd__decap_3
XFILLER_101_626 VGND VGND VPWR VPWR sky130_fd_sc_hd__decap_3
X_4275_ _4275_/A _4274_/Y VGND VGND VPWR VPWR _4620_/C sky130_fd_sc_hd__nor2b_2
XFILLER_98_197 VGND VGND VPWR VPWR sky130_fd_sc_hd__decap_3
XFILLER_100_147 VGND VGND VPWR VPWR sky130_fd_sc_hd__decap_3
XFILLER_39_220 VGND VGND VPWR VPWR sky130_fd_sc_hd__decap_3
XFILLER_39_231 VGND VGND VPWR VPWR sky130_fd_sc_hd__fill_1
XFILLER_27_415 VGND VGND VPWR VPWR sky130_fd_sc_hd__decap_3
XFILLER_39_264 VGND VGND VPWR VPWR sky130_fd_sc_hd__decap_3
XFILLER_67_573 VGND VGND VPWR VPWR sky130_fd_sc_hd__decap_3
XFILLER_82_521 VGND VGND VPWR VPWR sky130_fd_sc_hd__decap_3
XTAP_TAPCELL_ROW_68_1013 VGND VPWR sky130_fd_sc_hd__tapvpwrvgnd_1
XFILLER_54_245 VGND VGND VPWR VPWR sky130_fd_sc_hd__decap_3
XFILLER_14_109 VGND VGND VPWR VPWR sky130_fd_sc_hd__decap_3
XFILLER_54_267 VGND VGND VPWR VPWR sky130_fd_sc_hd__decap_3
XFILLER_23_610 VGND VGND VPWR VPWR sky130_fd_sc_hd__decap_3
XFILLER_23_632 VGND VGND VPWR VPWR sky130_fd_sc_hd__decap_3
X_6916_ _7071_/CLK _6916_/D VGND VGND VPWR VPWR _6916_/Q sky130_fd_sc_hd__dfxtp_2
XFILLER_22_131 VGND VGND VPWR VPWR sky130_fd_sc_hd__fill_1
X_6847_ _6958_/CLK _6847_/D VGND VGND VPWR VPWR _6847_/Q sky130_fd_sc_hd__dfxtp_2
XFILLER_10_315 VGND VGND VPWR VPWR sky130_fd_sc_hd__decap_3
X_6778_ clkload4/A _6778_/D VGND VGND VPWR VPWR _6778_/Q sky130_fd_sc_hd__dfxtp_2
XFILLER_10_337 VGND VGND VPWR VPWR sky130_fd_sc_hd__decap_3
XFILLER_22_186 VGND VGND VPWR VPWR sky130_fd_sc_hd__decap_3
XFILLER_22_197 VGND VGND VPWR VPWR sky130_fd_sc_hd__decap_3
XFILLER_50_495 VGND VGND VPWR VPWR sky130_fd_sc_hd__fill_1
X_5729_ _7370_/Q hold919/X _5737_/S VGND VGND VPWR VPWR _6714_/D sky130_fd_sc_hd__mux2_2
XFILLER_108_225 VGND VGND VPWR VPWR sky130_fd_sc_hd__decap_3
XTAP_TAPCELL_ROW_79_1142 VGND VPWR sky130_fd_sc_hd__tapvpwrvgnd_1
XFILLER_108_247 VGND VGND VPWR VPWR sky130_fd_sc_hd__decap_3
XFILLER_2_514 VGND VGND VPWR VPWR sky130_fd_sc_hd__decap_3
XFILLER_2_536 VGND VGND VPWR VPWR sky130_fd_sc_hd__decap_3
XFILLER_89_131 VGND VGND VPWR VPWR sky130_fd_sc_hd__decap_3
XFILLER_2_569 VGND VGND VPWR VPWR sky130_fd_sc_hd__decap_3
XFILLER_89_153 VGND VGND VPWR VPWR sky130_fd_sc_hd__fill_2
XFILLER_104_497 VGND VGND VPWR VPWR sky130_fd_sc_hd__fill_2
XFILLER_77_337 VGND VGND VPWR VPWR sky130_fd_sc_hd__decap_3
XFILLER_77_57 VGND VGND VPWR VPWR sky130_fd_sc_hd__decap_3
XFILLER_73_510 VGND VGND VPWR VPWR sky130_fd_sc_hd__decap_3
XFILLER_85_370 VGND VGND VPWR VPWR sky130_fd_sc_hd__decap_3
XFILLER_92_318 VGND VGND VPWR VPWR sky130_fd_sc_hd__decap_3
Xhold1060 _7390_/Q VGND VGND VPWR VPWR _3818_/A1 sky130_fd_sc_hd__dlygate4sd3_1
XFILLER_45_212 VGND VGND VPWR VPWR sky130_fd_sc_hd__decap_3
Xhold1071 _7347_/Q VGND VGND VPWR VPWR _5682_/A0 sky130_fd_sc_hd__dlygate4sd3_1
Xhold1082 _7251_/Q VGND VGND VPWR VPWR _5136_/A0 sky130_fd_sc_hd__dlygate4sd3_1
Xhold1093 _7256_/Q VGND VGND VPWR VPWR _5095_/A0 sky130_fd_sc_hd__dlygate4sd3_1
XFILLER_45_267 VGND VGND VPWR VPWR sky130_fd_sc_hd__decap_3
XFILLER_14_610 VGND VGND VPWR VPWR sky130_fd_sc_hd__decap_3
XFILLER_14_643 VGND VGND VPWR VPWR sky130_fd_sc_hd__fill_1
XFILLER_60_259 VGND VGND VPWR VPWR sky130_fd_sc_hd__decap_3
XFILLER_41_484 VGND VGND VPWR VPWR sky130_fd_sc_hd__decap_3
XFILLER_9_124 VGND VGND VPWR VPWR sky130_fd_sc_hd__decap_3
XFILLER_9_113 VGND VGND VPWR VPWR sky130_fd_sc_hd__decap_3
XFILLER_9_146 VGND VGND VPWR VPWR sky130_fd_sc_hd__decap_3
XTAP_TAPCELL_ROW_11_365 VGND VPWR sky130_fd_sc_hd__tapvpwrvgnd_1
XFILLER_5_330 VGND VGND VPWR VPWR sky130_fd_sc_hd__decap_3
XFILLER_5_396 VGND VGND VPWR VPWR sky130_fd_sc_hd__decap_3
XFILLER_96_613 VGND VGND VPWR VPWR sky130_fd_sc_hd__fill_2
XFILLER_68_315 VGND VGND VPWR VPWR sky130_fd_sc_hd__decap_3
XFILLER_68_337 VGND VGND VPWR VPWR sky130_fd_sc_hd__decap_3
XFILLER_95_145 VGND VGND VPWR VPWR sky130_fd_sc_hd__decap_3
XFILLER_95_156 VGND VGND VPWR VPWR sky130_fd_sc_hd__decap_3
X_4060_ _7084_/Q _4102_/B _4432_/B1 _4059_/X VGND VGND VPWR VPWR _4068_/A sky130_fd_sc_hd__o211a_2
XFILLER_36_212 VGND VGND VPWR VPWR sky130_fd_sc_hd__decap_3
XFILLER_76_392 VGND VGND VPWR VPWR sky130_fd_sc_hd__decap_3
XFILLER_36_256 VGND VGND VPWR VPWR sky130_fd_sc_hd__decap_3
XFILLER_91_340 VGND VGND VPWR VPWR sky130_fd_sc_hd__fill_1
XFILLER_91_362 VGND VGND VPWR VPWR sky130_fd_sc_hd__decap_3
XTAP_TAPCELL_ROW_47_774 VGND VPWR sky130_fd_sc_hd__tapvpwrvgnd_1
XTAP_TAPCELL_ROW_19_454 VGND VPWR sky130_fd_sc_hd__tapvpwrvgnd_1
XFILLER_17_470 VGND VGND VPWR VPWR sky130_fd_sc_hd__decap_3
XFILLER_17_492 VGND VGND VPWR VPWR sky130_fd_sc_hd__decap_3
X_4962_ _6994_/Q _4977_/A VGND VGND VPWR VPWR _4963_/B sky130_fd_sc_hd__nor2_2
X_6701_ _7071_/CLK _6701_/D VGND VGND VPWR VPWR _6701_/Q sky130_fd_sc_hd__dfxtp_2
X_4893_ _4928_/B _4943_/A _6996_/Q VGND VGND VPWR VPWR _4908_/B sky130_fd_sc_hd__o21a_2
X_3913_ _6857_/Q _3913_/A2 _3913_/B1 _6849_/Q _3912_/X VGND VGND VPWR VPWR _3913_/X
+ sky130_fd_sc_hd__a221o_2
XFILLER_20_613 VGND VGND VPWR VPWR sky130_fd_sc_hd__decap_3
X_6632_ _6632_/A VGND VGND VPWR VPWR _6632_/Y sky130_fd_sc_hd__inv_2
X_3844_ _3741_/X _3841_/X _3843_/X _5660_/A VGND VGND VPWR VPWR _3845_/B sky130_fd_sc_hd__a22o_2
X_6563_ _6566_/A VGND VGND VPWR VPWR _6563_/Y sky130_fd_sc_hd__inv_2
X_3775_ _3714_/X _3772_/X _3774_/X _3733_/X VGND VGND VPWR VPWR _3775_/X sky130_fd_sc_hd__a22o_2
X_6494_ _6589_/A VGND VGND VPWR VPWR _6494_/Y sky130_fd_sc_hd__inv_2
XFILLER_105_206 VGND VGND VPWR VPWR sky130_fd_sc_hd__decap_3
XFILLER_105_228 VGND VGND VPWR VPWR sky130_fd_sc_hd__decap_3
X_7115_ _7373_/CLK _7115_/D _6395_/Y VGND VGND VPWR VPWR _7115_/Q sky130_fd_sc_hd__dfrtp_2
Xoutput487 _5658_/D VGND VGND VPWR VPWR alu_result_out[7] sky130_fd_sc_hd__clkdlybuf4s25_1
Xoutput476 _5656_/A VGND VGND VPWR VPWR alu_result_out[26] sky130_fd_sc_hd__clkdlybuf4s25_1
Xoutput465 _4973_/B VGND VGND VPWR VPWR alu_result_out[16] sky130_fd_sc_hd__clkdlybuf4s25_1
XFILLER_87_635 VGND VGND VPWR VPWR sky130_fd_sc_hd__decap_3
Xoutput498 _5161_/A VGND VGND VPWR VPWR instruction_out[18] sky130_fd_sc_hd__clkdlybuf4s25_1
X_4327_ _4327_/A _4327_/B VGND VGND VPWR VPWR _4362_/C sky130_fd_sc_hd__nand2_2
XTAP_TAPCELL_ROW_74_1083 VGND VPWR sky130_fd_sc_hd__tapvpwrvgnd_1
XFILLER_99_484 VGND VGND VPWR VPWR sky130_fd_sc_hd__fill_1
XFILLER_101_434 VGND VGND VPWR VPWR sky130_fd_sc_hd__decap_3
XFILLER_59_348 VGND VGND VPWR VPWR sky130_fd_sc_hd__decap_3
XFILLER_59_359 VGND VGND VPWR VPWR sky130_fd_sc_hd__decap_3
XFILLER_86_134 VGND VGND VPWR VPWR sky130_fd_sc_hd__decap_3
X_7046_ _7392_/CLK _7046_/D _6326_/Y VGND VGND VPWR VPWR _7046_/Q sky130_fd_sc_hd__dfrtp_2
X_4258_ _4988_/A _4988_/B VGND VGND VPWR VPWR _5003_/A sky130_fd_sc_hd__or2_4
XFILLER_101_467 VGND VGND VPWR VPWR sky130_fd_sc_hd__decap_3
XFILLER_27_201 VGND VGND VPWR VPWR sky130_fd_sc_hd__fill_2
XFILLER_103_33 VGND VGND VPWR VPWR sky130_fd_sc_hd__decap_3
XFILLER_55_532 VGND VGND VPWR VPWR sky130_fd_sc_hd__decap_3
X_4189_ _7231_/Q _4214_/A2 _4261_/B1 _7167_/Q _4188_/X VGND VGND VPWR VPWR _4189_/X
+ sky130_fd_sc_hd__a221o_2
XFILLER_103_55 VGND VGND VPWR VPWR sky130_fd_sc_hd__fill_1
XFILLER_27_256 VGND VGND VPWR VPWR sky130_fd_sc_hd__decap_3
XFILLER_42_215 VGND VGND VPWR VPWR sky130_fd_sc_hd__decap_3
XFILLER_55_598 VGND VGND VPWR VPWR sky130_fd_sc_hd__decap_3
XFILLER_63_26 VGND VGND VPWR VPWR sky130_fd_sc_hd__decap_3
XFILLER_82_395 VGND VGND VPWR VPWR sky130_fd_sc_hd__decap_3
XFILLER_23_440 VGND VGND VPWR VPWR sky130_fd_sc_hd__decap_3
XFILLER_11_635 VGND VGND VPWR VPWR sky130_fd_sc_hd__decap_3
XFILLER_7_606 VGND VGND VPWR VPWR sky130_fd_sc_hd__decap_3
XFILLER_7_617 VGND VGND VPWR VPWR sky130_fd_sc_hd__decap_3
XFILLER_12_52 VGND VGND VPWR VPWR sky130_fd_sc_hd__decap_3
Xwire559 _4273_/Y VGND VGND VPWR VPWR wire559/X sky130_fd_sc_hd__clkdlybuf4s25_1
XFILLER_12_96 VGND VGND VPWR VPWR sky130_fd_sc_hd__decap_3
XFILLER_2_300 VGND VGND VPWR VPWR sky130_fd_sc_hd__decap_3
XFILLER_2_355 VGND VGND VPWR VPWR sky130_fd_sc_hd__decap_3
XFILLER_78_635 VGND VGND VPWR VPWR sky130_fd_sc_hd__decap_3
XFILLER_104_294 VGND VGND VPWR VPWR sky130_fd_sc_hd__decap_3
XFILLER_77_134 VGND VGND VPWR VPWR sky130_fd_sc_hd__decap_3
XFILLER_77_167 VGND VGND VPWR VPWR sky130_fd_sc_hd__fill_1
XFILLER_77_178 VGND VGND VPWR VPWR sky130_fd_sc_hd__decap_3
XFILLER_93_638 VGND VGND VPWR VPWR sky130_fd_sc_hd__decap_3
XFILLER_18_212 VGND VGND VPWR VPWR sky130_fd_sc_hd__decap_3
XFILLER_92_137 VGND VGND VPWR VPWR sky130_fd_sc_hd__decap_3
XFILLER_61_502 VGND VGND VPWR VPWR sky130_fd_sc_hd__fill_2
XFILLER_73_340 VGND VGND VPWR VPWR sky130_fd_sc_hd__decap_3
XFILLER_92_159 VGND VGND VPWR VPWR sky130_fd_sc_hd__decap_3
XPHY_EDGE_ROW_16_Right_16 VGND VGND VPWR VPWR sky130_fd_sc_hd__decap_3
XFILLER_18_278 VGND VGND VPWR VPWR sky130_fd_sc_hd__decap_3
XFILLER_61_535 VGND VGND VPWR VPWR sky130_fd_sc_hd__decap_3
XFILLER_73_373 VGND VGND VPWR VPWR sky130_fd_sc_hd__decap_3
XTAP_TAPCELL_ROW_16_424 VGND VPWR sky130_fd_sc_hd__tapvpwrvgnd_1
XTAP_TAPCELL_ROW_16_413 VGND VPWR sky130_fd_sc_hd__tapvpwrvgnd_1
XTAP_TAPCELL_ROW_44_744 VGND VPWR sky130_fd_sc_hd__tapvpwrvgnd_1
XFILLER_41_281 VGND VGND VPWR VPWR sky130_fd_sc_hd__decap_3
X_3560_ _5118_/D _3560_/B VGND VGND VPWR VPWR _3562_/B sky130_fd_sc_hd__nor2_2
XPHY_EDGE_ROW_25_Right_25 VGND VGND VPWR VPWR sky130_fd_sc_hd__decap_3
XFILLER_5_160 VGND VGND VPWR VPWR sky130_fd_sc_hd__decap_3
X_3491_ _7215_/Q _3377_/X _3366_/X _7151_/Q _3490_/X VGND VGND VPWR VPWR _3491_/X
+ sky130_fd_sc_hd__a221o_2
XFILLER_102_209 VGND VGND VPWR VPWR sky130_fd_sc_hd__decap_3
XFILLER_45_3 VGND VGND VPWR VPWR sky130_fd_sc_hd__decap_3
XFILLER_69_635 VGND VGND VPWR VPWR sky130_fd_sc_hd__decap_3
X_5161_ _5161_/A _5641_/A VGND VGND VPWR VPWR _5225_/B sky130_fd_sc_hd__or2_2
X_5092_ _5069_/B _5092_/B _5092_/C VGND VGND VPWR VPWR _5092_/X sky130_fd_sc_hd__and3b_2
X_4112_ _7332_/Q _3958_/S _4495_/S _7300_/Q VGND VGND VPWR VPWR _4112_/X sky130_fd_sc_hd__a22o_2
XFILLER_56_318 VGND VGND VPWR VPWR sky130_fd_sc_hd__decap_3
X_4043_ _7309_/Q _4478_/S _4459_/C1 _7181_/Q _4042_/X VGND VGND VPWR VPWR _4043_/X
+ sky130_fd_sc_hd__a221o_2
XFILLER_49_370 VGND VGND VPWR VPWR sky130_fd_sc_hd__decap_3
XFILLER_83_137 VGND VGND VPWR VPWR sky130_fd_sc_hd__decap_3
XPHY_EDGE_ROW_34_Right_34 VGND VGND VPWR VPWR sky130_fd_sc_hd__decap_3
XFILLER_37_576 VGND VGND VPWR VPWR sky130_fd_sc_hd__decap_3
XFILLER_64_362 VGND VGND VPWR VPWR sky130_fd_sc_hd__fill_2
XFILLER_24_215 VGND VGND VPWR VPWR sky130_fd_sc_hd__decap_3
XFILLER_37_598 VGND VGND VPWR VPWR sky130_fd_sc_hd__decap_3
XFILLER_64_395 VGND VGND VPWR VPWR sky130_fd_sc_hd__decap_3
XFILLER_91_181 VGND VGND VPWR VPWR sky130_fd_sc_hd__fill_2
XTAP_TAPCELL_ROW_108_1488 VGND VPWR sky130_fd_sc_hd__tapvpwrvgnd_1
XTAP_TAPCELL_ROW_108_1477 VGND VPWR sky130_fd_sc_hd__tapvpwrvgnd_1
XFILLER_24_259 VGND VGND VPWR VPWR sky130_fd_sc_hd__decap_3
X_4945_ _5061_/S _6995_/D _5657_/C _4944_/X VGND VGND VPWR VPWR _4945_/X sky130_fd_sc_hd__o22a_2
XFILLER_20_421 VGND VGND VPWR VPWR sky130_fd_sc_hd__fill_2
XFILLER_20_432 VGND VGND VPWR VPWR sky130_fd_sc_hd__decap_3
X_6615_ _6619_/A VGND VGND VPWR VPWR _6615_/Y sky130_fd_sc_hd__inv_2
X_3827_ _6700_/Q _3911_/A2 _3911_/B1 _6878_/Q VGND VGND VPWR VPWR _3827_/X sky130_fd_sc_hd__a22o_2
XPHY_EDGE_ROW_43_Right_43 VGND VGND VPWR VPWR sky130_fd_sc_hd__decap_3
X_6546_ _6546_/A VGND VGND VPWR VPWR _6546_/Y sky130_fd_sc_hd__inv_2
XTAP_TAPCELL_ROW_76_1112 VGND VPWR sky130_fd_sc_hd__tapvpwrvgnd_1
X_6477_ _6541_/A VGND VGND VPWR VPWR _6477_/Y sky130_fd_sc_hd__inv_2
XPHY_EDGE_ROW_18_Left_127 VGND VGND VPWR VPWR sky130_fd_sc_hd__decap_3
XFILLER_106_559 VGND VGND VPWR VPWR sky130_fd_sc_hd__decap_3
XFILLER_99_281 VGND VGND VPWR VPWR sky130_fd_sc_hd__decap_3
XFILLER_99_270 VGND VGND VPWR VPWR sky130_fd_sc_hd__decap_3
XFILLER_101_231 VGND VGND VPWR VPWR sky130_fd_sc_hd__decap_3
XFILLER_58_59 VGND VGND VPWR VPWR sky130_fd_sc_hd__decap_3
XFILLER_87_443 VGND VGND VPWR VPWR sky130_fd_sc_hd__decap_3
XFILLER_101_275 VGND VGND VPWR VPWR sky130_fd_sc_hd__decap_3
XFILLER_59_156 VGND VGND VPWR VPWR sky130_fd_sc_hd__decap_3
XFILLER_59_178 VGND VGND VPWR VPWR sky130_fd_sc_hd__decap_3
XFILLER_75_638 VGND VGND VPWR VPWR sky130_fd_sc_hd__decap_3
X_7029_ _7376_/CLK _7029_/D _6309_/Y VGND VGND VPWR VPWR _7029_/Q sky130_fd_sc_hd__dfrtp_2
XPHY_EDGE_ROW_52_Right_52 VGND VGND VPWR VPWR sky130_fd_sc_hd__decap_3
XFILLER_55_340 VGND VGND VPWR VPWR sky130_fd_sc_hd__decap_3
XFILLER_74_159 VGND VGND VPWR VPWR sky130_fd_sc_hd__decap_3
XFILLER_74_47 VGND VGND VPWR VPWR sky130_fd_sc_hd__decap_3
XTAP_TAPCELL_ROW_87_1230 VGND VPWR sky130_fd_sc_hd__tapvpwrvgnd_1
XPHY_EDGE_ROW_27_Left_136 VGND VGND VPWR VPWR sky130_fd_sc_hd__decap_3
XFILLER_28_598 VGND VGND VPWR VPWR sky130_fd_sc_hd__decap_3
XFILLER_55_384 VGND VGND VPWR VPWR sky130_fd_sc_hd__decap_3
XFILLER_74_69 VGND VGND VPWR VPWR sky130_fd_sc_hd__decap_3
XFILLER_70_343 VGND VGND VPWR VPWR sky130_fd_sc_hd__fill_1
XFILLER_30_218 VGND VGND VPWR VPWR sky130_fd_sc_hd__decap_3
XFILLER_70_365 VGND VGND VPWR VPWR sky130_fd_sc_hd__decap_3
XFILLER_90_24 VGND VGND VPWR VPWR sky130_fd_sc_hd__decap_3
XTAP_TAPCELL_ROW_41_703 VGND VPWR sky130_fd_sc_hd__tapvpwrvgnd_1
XFILLER_11_432 VGND VGND VPWR VPWR sky130_fd_sc_hd__fill_1
XFILLER_70_398 VGND VGND VPWR VPWR sky130_fd_sc_hd__decap_3
XFILLER_90_79 VGND VGND VPWR VPWR sky130_fd_sc_hd__decap_3
XPHY_EDGE_ROW_61_Right_61 VGND VGND VPWR VPWR sky130_fd_sc_hd__decap_3
XFILLER_11_476 VGND VGND VPWR VPWR sky130_fd_sc_hd__decap_3
XFILLER_11_487 VGND VGND VPWR VPWR sky130_fd_sc_hd__decap_3
XFILLER_23_84 VGND VGND VPWR VPWR sky130_fd_sc_hd__fill_1
XFILLER_7_447 VGND VGND VPWR VPWR sky130_fd_sc_hd__fill_1
XTAP_TAPCELL_ROW_21_471 VGND VPWR sky130_fd_sc_hd__tapvpwrvgnd_1
XPHY_EDGE_ROW_36_Left_145 VGND VGND VPWR VPWR sky130_fd_sc_hd__decap_3
XFILLER_3_620 VGND VGND VPWR VPWR sky130_fd_sc_hd__decap_3
XFILLER_2_141 VGND VGND VPWR VPWR sky130_fd_sc_hd__decap_3
XFILLER_2_174 VGND VGND VPWR VPWR sky130_fd_sc_hd__decap_3
XPHY_EDGE_ROW_70_Right_70 VGND VGND VPWR VPWR sky130_fd_sc_hd__decap_3
XFILLER_78_454 VGND VGND VPWR VPWR sky130_fd_sc_hd__fill_2
XFILLER_66_616 VGND VGND VPWR VPWR sky130_fd_sc_hd__decap_3
XFILLER_93_402 VGND VGND VPWR VPWR sky130_fd_sc_hd__decap_3
XTAP_TAPCELL_ROW_49_803 VGND VPWR sky130_fd_sc_hd__tapvpwrvgnd_1
XFILLER_0_11 VGND VGND VPWR VPWR sky130_fd_sc_hd__decap_3
Xsingle_cycle_cpu_577 VGND VGND VPWR VPWR instruction_out[0] single_cycle_cpu_577/LO
+ sky130_fd_sc_hd__conb_1
XPHY_EDGE_ROW_45_Left_154 VGND VGND VPWR VPWR sky130_fd_sc_hd__decap_3
XFILLER_65_148 VGND VGND VPWR VPWR sky130_fd_sc_hd__decap_3
XFILLER_65_159 VGND VGND VPWR VPWR sky130_fd_sc_hd__decap_3
XFILLER_34_524 VGND VGND VPWR VPWR sky130_fd_sc_hd__decap_3
XFILLER_61_310 VGND VGND VPWR VPWR sky130_fd_sc_hd__decap_3
XFILLER_80_118 VGND VGND VPWR VPWR sky130_fd_sc_hd__decap_3
XTAP_TAPCELL_ROW_57_891 VGND VPWR sky130_fd_sc_hd__tapvpwrvgnd_1
XTAP_TAPCELL_ROW_29_571 VGND VPWR sky130_fd_sc_hd__tapvpwrvgnd_1
XFILLER_73_181 VGND VGND VPWR VPWR sky130_fd_sc_hd__decap_3
XFILLER_73_192 VGND VGND VPWR VPWR sky130_fd_sc_hd__decap_3
XFILLER_21_207 VGND VGND VPWR VPWR sky130_fd_sc_hd__decap_3
XFILLER_34_579 VGND VGND VPWR VPWR sky130_fd_sc_hd__decap_3
XFILLER_14_292 VGND VGND VPWR VPWR sky130_fd_sc_hd__decap_3
X_4730_ _7007_/Q _4738_/A VGND VGND VPWR VPWR _4731_/A sky130_fd_sc_hd__or2_2
XFILLER_9_53 VGND VGND VPWR VPWR sky130_fd_sc_hd__decap_3
X_7380_ _7380_/CLK _7380_/D _6660_/Y VGND VGND VPWR VPWR _7380_/Q sky130_fd_sc_hd__dfrtp_2
X_6400_ _6632_/A VGND VGND VPWR VPWR _6400_/Y sky130_fd_sc_hd__inv_2
X_3612_ _3536_/B _4614_/B _3610_/Y _3611_/Y VGND VGND VPWR VPWR _3612_/X sky130_fd_sc_hd__a211o_2
XPHY_EDGE_ROW_54_Left_163 VGND VGND VPWR VPWR sky130_fd_sc_hd__decap_3
Xhold904 _6696_/Q VGND VGND VPWR VPWR hold904/X sky130_fd_sc_hd__dlygate4sd3_1
X_6331_ _6552_/A VGND VGND VPWR VPWR _6331_/Y sky130_fd_sc_hd__inv_2
Xhold915 _6709_/Q VGND VGND VPWR VPWR hold915/X sky130_fd_sc_hd__dlygate4sd3_1
Xhold926 _7021_/Q VGND VGND VPWR VPWR _5613_/A sky130_fd_sc_hd__dlygate4sd3_1
Xhold937 _7311_/Q VGND VGND VPWR VPWR hold937/X sky130_fd_sc_hd__dlygate4sd3_1
X_3543_ _3540_/X _3541_/X _5144_/A VGND VGND VPWR VPWR _3630_/B sky130_fd_sc_hd__o21ai_2
Xhold959 _7394_/Q VGND VGND VPWR VPWR hold959/X sky130_fd_sc_hd__dlygate4sd3_1
Xhold948 _7029_/Q VGND VGND VPWR VPWR hold948/X sky130_fd_sc_hd__dlygate4sd3_1
X_6262_ _6463_/A VGND VGND VPWR VPWR _6262_/Y sky130_fd_sc_hd__inv_2
X_3474_ _7280_/Q _4534_/S _4348_/A2 _7152_/Q _3473_/X VGND VGND VPWR VPWR _3474_/X
+ sky130_fd_sc_hd__a221o_2
XFILLER_88_229 VGND VGND VPWR VPWR sky130_fd_sc_hd__decap_3
X_5213_ _5213_/A _5223_/B VGND VGND VPWR VPWR _7222_/D sky130_fd_sc_hd__and2_2
X_5144_ _5144_/A _5144_/B VGND VGND VPWR VPWR _5145_/A sky130_fd_sc_hd__nand2_2
XTAP_TAPCELL_ROW_71_1053 VGND VPWR sky130_fd_sc_hd__tapvpwrvgnd_1
XFILLER_84_402 VGND VGND VPWR VPWR sky130_fd_sc_hd__decap_3
XPHY_EDGE_ROW_63_Left_172 VGND VGND VPWR VPWR sky130_fd_sc_hd__decap_3
XFILLER_29_329 VGND VGND VPWR VPWR sky130_fd_sc_hd__decap_3
XFILLER_56_126 VGND VGND VPWR VPWR sky130_fd_sc_hd__decap_3
XFILLER_57_638 VGND VGND VPWR VPWR sky130_fd_sc_hd__decap_3
XFILLER_84_424 VGND VGND VPWR VPWR sky130_fd_sc_hd__decap_3
X_5075_ _5075_/A _5075_/B _5075_/C VGND VGND VPWR VPWR _5658_/A sky130_fd_sc_hd__or3_2
XFILLER_96_284 VGND VGND VPWR VPWR sky130_fd_sc_hd__decap_3
XFILLER_37_340 VGND VGND VPWR VPWR sky130_fd_sc_hd__decap_3
XFILLER_64_181 VGND VGND VPWR VPWR sky130_fd_sc_hd__decap_3
XFILLER_92_490 VGND VGND VPWR VPWR sky130_fd_sc_hd__decap_3
XFILLER_12_218 VGND VGND VPWR VPWR sky130_fd_sc_hd__decap_3
XFILLER_52_365 VGND VGND VPWR VPWR sky130_fd_sc_hd__decap_3
XFILLER_100_23 VGND VGND VPWR VPWR sky130_fd_sc_hd__decap_3
X_4928_ _6996_/Q _4928_/B _4943_/A VGND VGND VPWR VPWR _4928_/Y sky130_fd_sc_hd__nor3_2
XTAP_TAPCELL_ROW_82_1182 VGND VPWR sky130_fd_sc_hd__tapvpwrvgnd_1
XPHY_EDGE_ROW_72_Left_181 VGND VGND VPWR VPWR sky130_fd_sc_hd__decap_3
XFILLER_20_284 VGND VGND VPWR VPWR sky130_fd_sc_hd__decap_3
X_4859_ _7000_/Q _4870_/A VGND VGND VPWR VPWR _4859_/Y sky130_fd_sc_hd__nor2_2
Xclkbuf_3_0__f_clk clkbuf_0_clk/X VGND VGND VPWR VPWR clkbuf_leaf_2_clk/A sky130_fd_sc_hd__clkbuf_16
XFILLER_4_417 VGND VGND VPWR VPWR sky130_fd_sc_hd__decap_3
X_6529_ _6635_/A VGND VGND VPWR VPWR _6529_/Y sky130_fd_sc_hd__inv_2
XFILLER_106_356 VGND VGND VPWR VPWR sky130_fd_sc_hd__decap_3
XPHY_EDGE_ROW_81_Left_190 VGND VGND VPWR VPWR sky130_fd_sc_hd__decap_3
XFILLER_102_551 VGND VGND VPWR VPWR sky130_fd_sc_hd__fill_2
XFILLER_48_616 VGND VGND VPWR VPWR sky130_fd_sc_hd__decap_3
XFILLER_85_35 VGND VGND VPWR VPWR sky130_fd_sc_hd__fill_1
XFILLER_102_595 VGND VGND VPWR VPWR sky130_fd_sc_hd__decap_3
XFILLER_47_137 VGND VGND VPWR VPWR sky130_fd_sc_hd__decap_3
XFILLER_75_435 VGND VGND VPWR VPWR sky130_fd_sc_hd__decap_3
XFILLER_85_57 VGND VGND VPWR VPWR sky130_fd_sc_hd__decap_3
XFILLER_28_351 VGND VGND VPWR VPWR sky130_fd_sc_hd__decap_3
XFILLER_90_405 VGND VGND VPWR VPWR sky130_fd_sc_hd__decap_3
XFILLER_43_310 VGND VGND VPWR VPWR sky130_fd_sc_hd__fill_1
XFILLER_62_107 VGND VGND VPWR VPWR sky130_fd_sc_hd__decap_3
XFILLER_90_438 VGND VGND VPWR VPWR sky130_fd_sc_hd__fill_2
XFILLER_55_181 VGND VGND VPWR VPWR sky130_fd_sc_hd__decap_3
XFILLER_71_641 VGND VGND VPWR VPWR sky130_fd_sc_hd__decap_3
XTAP_TAPCELL_ROW_26_530 VGND VPWR sky130_fd_sc_hd__tapvpwrvgnd_1
XFILLER_70_162 VGND VGND VPWR VPWR sky130_fd_sc_hd__decap_3
XTAP_TAPCELL_ROW_54_861 VGND VPWR sky130_fd_sc_hd__tapvpwrvgnd_1
XTAP_TAPCELL_ROW_54_850 VGND VPWR sky130_fd_sc_hd__tapvpwrvgnd_1
XFILLER_70_184 VGND VGND VPWR VPWR sky130_fd_sc_hd__decap_3
XFILLER_34_94 VGND VGND VPWR VPWR sky130_fd_sc_hd__decap_3
XFILLER_11_251 VGND VGND VPWR VPWR sky130_fd_sc_hd__decap_3
XFILLER_11_284 VGND VGND VPWR VPWR sky130_fd_sc_hd__decap_3
XFILLER_7_222 VGND VGND VPWR VPWR sky130_fd_sc_hd__fill_2
XFILLER_7_255 VGND VGND VPWR VPWR sky130_fd_sc_hd__decap_3
XFILLER_50_71 VGND VGND VPWR VPWR sky130_fd_sc_hd__decap_3
XFILLER_7_288 VGND VGND VPWR VPWR sky130_fd_sc_hd__decap_3
XFILLER_39_638 VGND VGND VPWR VPWR sky130_fd_sc_hd__decap_3
XFILLER_93_210 VGND VGND VPWR VPWR sky130_fd_sc_hd__decap_3
XFILLER_19_340 VGND VGND VPWR VPWR sky130_fd_sc_hd__fill_1
XFILLER_54_608 VGND VGND VPWR VPWR sky130_fd_sc_hd__decap_3
XFILLER_93_265 VGND VGND VPWR VPWR sky130_fd_sc_hd__decap_3
XFILLER_19_373 VGND VGND VPWR VPWR sky130_fd_sc_hd__fill_1
XFILLER_81_427 VGND VGND VPWR VPWR sky130_fd_sc_hd__decap_3
XFILLER_62_630 VGND VGND VPWR VPWR sky130_fd_sc_hd__decap_3
X_6880_ _7071_/CLK _6880_/D VGND VGND VPWR VPWR _6880_/Q sky130_fd_sc_hd__dfxtp_2
XTAP_TAPCELL_ROW_105_1447 VGND VPWR sky130_fd_sc_hd__tapvpwrvgnd_1
XFILLER_34_365 VGND VGND VPWR VPWR sky130_fd_sc_hd__decap_3
X_4713_ _7008_/Q _4731_/B VGND VGND VPWR VPWR _7008_/D sky130_fd_sc_hd__xnor2_2
XFILLER_30_582 VGND VGND VPWR VPWR sky130_fd_sc_hd__decap_3
X_5693_ _7352_/Q hold904/X _5697_/S VGND VGND VPWR VPWR _6696_/D sky130_fd_sc_hd__mux2_2
XTAP_TAPCELL_ROW_32_599 VGND VPWR sky130_fd_sc_hd__tapvpwrvgnd_1
XFILLER_107_109 VGND VGND VPWR VPWR sky130_fd_sc_hd__decap_3
X_4644_ _4111_/B _4643_/Y _4633_/A _4109_/X VGND VGND VPWR VPWR _4644_/X sky130_fd_sc_hd__a211o_2
X_7363_ _7363_/CLK _7363_/D _6643_/Y VGND VGND VPWR VPWR _7363_/Q sky130_fd_sc_hd__dfrtp_2
Xhold701 _6766_/Q VGND VGND VPWR VPWR _6766_/D sky130_fd_sc_hd__dlygate4sd3_1
Xhold712 _6740_/Q VGND VGND VPWR VPWR _6740_/D sky130_fd_sc_hd__dlygate4sd3_1
X_4575_ _4575_/A _4589_/B VGND VGND VPWR VPWR _7293_/D sky130_fd_sc_hd__and2_2
XFILLER_89_505 VGND VGND VPWR VPWR sky130_fd_sc_hd__decap_3
X_7294_ _7364_/CLK _7294_/D _6574_/Y VGND VGND VPWR VPWR _7294_/Q sky130_fd_sc_hd__dfrtp_2
Xhold723 _6829_/Q VGND VGND VPWR VPWR _6829_/D sky130_fd_sc_hd__dlygate4sd3_1
Xhold734 _6732_/Q VGND VGND VPWR VPWR _6732_/D sky130_fd_sc_hd__dlygate4sd3_1
Xhold745 _6850_/Q VGND VGND VPWR VPWR _6850_/D sky130_fd_sc_hd__dlygate4sd3_1
X_6314_ _6632_/A VGND VGND VPWR VPWR _6314_/Y sky130_fd_sc_hd__inv_2
X_3526_ _4938_/A _5114_/A VGND VGND VPWR VPWR _5057_/A sky130_fd_sc_hd__nand2_2
XFILLER_89_516 VGND VGND VPWR VPWR sky130_fd_sc_hd__fill_2
Xhold756 _6754_/Q VGND VGND VPWR VPWR _6754_/D sky130_fd_sc_hd__dlygate4sd3_1
Xhold767 _6930_/Q VGND VGND VPWR VPWR _6930_/D sky130_fd_sc_hd__dlygate4sd3_1
Xhold778 _6758_/Q VGND VGND VPWR VPWR _6758_/D sky130_fd_sc_hd__dlygate4sd3_1
XFILLER_103_337 VGND VGND VPWR VPWR sky130_fd_sc_hd__decap_3
XFILLER_39_28 VGND VGND VPWR VPWR sky130_fd_sc_hd__fill_2
Xhold789 _6900_/Q VGND VGND VPWR VPWR _6900_/D sky130_fd_sc_hd__dlygate4sd3_1
X_3457_ _4394_/A _3449_/C _4327_/A _3456_/X VGND VGND VPWR VPWR _3506_/B sky130_fd_sc_hd__a22o_2
X_3388_ _3394_/A _3429_/B VGND VGND VPWR VPWR _3388_/Y sky130_fd_sc_hd__nor2_2
XFILLER_69_284 VGND VGND VPWR VPWR sky130_fd_sc_hd__decap_3
XFILLER_29_148 VGND VGND VPWR VPWR sky130_fd_sc_hd__decap_3
X_5058_ _5072_/A _4330_/B _5056_/X _5057_/Y VGND VGND VPWR VPWR _5662_/B sky130_fd_sc_hd__a211o_2
XPHY_EDGE_ROW_2_Right_2 VGND VGND VPWR VPWR sky130_fd_sc_hd__decap_3
XFILLER_44_129 VGND VGND VPWR VPWR sky130_fd_sc_hd__decap_3
XFILLER_72_427 VGND VGND VPWR VPWR sky130_fd_sc_hd__decap_3
XFILLER_84_298 VGND VGND VPWR VPWR sky130_fd_sc_hd__decap_3
XTAP_TAPCELL_ROW_84_1200 VGND VPWR sky130_fd_sc_hd__tapvpwrvgnd_1
XFILLER_53_641 VGND VGND VPWR VPWR sky130_fd_sc_hd__decap_3
XFILLER_65_490 VGND VGND VPWR VPWR sky130_fd_sc_hd__decap_3
XFILLER_25_365 VGND VGND VPWR VPWR sky130_fd_sc_hd__decap_3
XFILLER_80_471 VGND VGND VPWR VPWR sky130_fd_sc_hd__decap_3
XFILLER_13_527 VGND VGND VPWR VPWR sky130_fd_sc_hd__decap_3
XFILLER_40_324 VGND VGND VPWR VPWR sky130_fd_sc_hd__decap_3
XFILLER_52_195 VGND VGND VPWR VPWR sky130_fd_sc_hd__fill_1
XFILLER_80_493 VGND VGND VPWR VPWR sky130_fd_sc_hd__decap_3
XTAP_TAPCELL_ROW_51_820 VGND VPWR sky130_fd_sc_hd__tapvpwrvgnd_1
XTAP_TAPCELL_ROW_23_500 VGND VPWR sky130_fd_sc_hd__tapvpwrvgnd_1
XFILLER_40_368 VGND VGND VPWR VPWR sky130_fd_sc_hd__decap_3
XFILLER_21_593 VGND VGND VPWR VPWR sky130_fd_sc_hd__decap_3
XFILLER_106_131 VGND VGND VPWR VPWR sky130_fd_sc_hd__decap_3
XFILLER_106_164 VGND VGND VPWR VPWR sky130_fd_sc_hd__decap_3
XFILLER_20_63 VGND VGND VPWR VPWR sky130_fd_sc_hd__decap_3
XFILLER_20_85 VGND VGND VPWR VPWR sky130_fd_sc_hd__decap_3
XFILLER_4_269 VGND VGND VPWR VPWR sky130_fd_sc_hd__decap_3
XFILLER_88_571 VGND VGND VPWR VPWR sky130_fd_sc_hd__fill_1
XFILLER_95_508 VGND VGND VPWR VPWR sky130_fd_sc_hd__fill_1
XFILLER_29_50 VGND VGND VPWR VPWR sky130_fd_sc_hd__decap_3
XFILLER_48_424 VGND VGND VPWR VPWR sky130_fd_sc_hd__decap_3
XFILLER_102_392 VGND VGND VPWR VPWR sky130_fd_sc_hd__decap_3
XFILLER_36_608 VGND VGND VPWR VPWR sky130_fd_sc_hd__decap_3
XFILLER_75_232 VGND VGND VPWR VPWR sky130_fd_sc_hd__decap_3
XFILLER_75_265 VGND VGND VPWR VPWR sky130_fd_sc_hd__decap_3
XFILLER_16_321 VGND VGND VPWR VPWR sky130_fd_sc_hd__decap_3
XFILLER_16_332 VGND VGND VPWR VPWR sky130_fd_sc_hd__decap_3
XFILLER_28_170 VGND VGND VPWR VPWR sky130_fd_sc_hd__fill_2
XFILLER_28_192 VGND VGND VPWR VPWR sky130_fd_sc_hd__decap_3
XFILLER_63_449 VGND VGND VPWR VPWR sky130_fd_sc_hd__decap_3
XFILLER_75_298 VGND VGND VPWR VPWR sky130_fd_sc_hd__decap_3
Xplace405 _4532_/S VGND VGND VPWR VPWR _4528_/B sky130_fd_sc_hd__buf_2
Xplace416 _3945_/S VGND VGND VPWR VPWR _3939_/S sky130_fd_sc_hd__buf_2
Xplace427 _3371_/Y VGND VGND VPWR VPWR _4471_/S sky130_fd_sc_hd__buf_2
Xplace438 _4667_/B VGND VGND VPWR VPWR _5634_/B sky130_fd_sc_hd__buf_2
XFILLER_16_365 VGND VGND VPWR VPWR sky130_fd_sc_hd__decap_3
Xplace449 _3561_/A VGND VGND VPWR VPWR _5129_/A sky130_fd_sc_hd__buf_2
XFILLER_71_482 VGND VGND VPWR VPWR sky130_fd_sc_hd__decap_3
XFILLER_31_346 VGND VGND VPWR VPWR sky130_fd_sc_hd__fill_2
XFILLER_31_357 VGND VGND VPWR VPWR sky130_fd_sc_hd__fill_1
XFILLER_12_582 VGND VGND VPWR VPWR sky130_fd_sc_hd__decap_3
XFILLER_31_379 VGND VGND VPWR VPWR sky130_fd_sc_hd__fill_2
XFILLER_8_531 VGND VGND VPWR VPWR sky130_fd_sc_hd__fill_1
XFILLER_8_542 VGND VGND VPWR VPWR sky130_fd_sc_hd__fill_1
XTAP_TAPCELL_ROW_100_1388 VGND VPWR sky130_fd_sc_hd__tapvpwrvgnd_1
XANTENNA_3 reset VGND VGND VPWR VPWR sky130_fd_sc_hd__diode_2
XFILLER_8_575 VGND VGND VPWR VPWR sky130_fd_sc_hd__decap_3
X_4360_ _5072_/B _5071_/B VGND VGND VPWR VPWR _5073_/A sky130_fd_sc_hd__nand2_2
X_3311_ _5118_/C _4696_/B _3340_/B VGND VGND VPWR VPWR _5671_/A sky130_fd_sc_hd__o21ai_2
X_4291_ _4294_/A _4612_/B VGND VGND VPWR VPWR _4292_/C sky130_fd_sc_hd__xnor2_2
XFILLER_39_402 VGND VGND VPWR VPWR sky130_fd_sc_hd__decap_3
XFILLER_3_291 VGND VGND VPWR VPWR sky130_fd_sc_hd__decap_3
XFILLER_98_368 VGND VGND VPWR VPWR sky130_fd_sc_hd__fill_1
XFILLER_100_318 VGND VGND VPWR VPWR sky130_fd_sc_hd__decap_3
XFILLER_66_232 VGND VGND VPWR VPWR sky130_fd_sc_hd__decap_3
XFILLER_94_530 VGND VGND VPWR VPWR sky130_fd_sc_hd__fill_2
XFILLER_94_563 VGND VGND VPWR VPWR sky130_fd_sc_hd__decap_3
XFILLER_81_202 VGND VGND VPWR VPWR sky130_fd_sc_hd__decap_3
XFILLER_19_181 VGND VGND VPWR VPWR sky130_fd_sc_hd__decap_3
XFILLER_35_641 VGND VGND VPWR VPWR sky130_fd_sc_hd__decap_3
X_6932_ _6968_/CLK _6932_/D VGND VGND VPWR VPWR _6932_/Q sky130_fd_sc_hd__dfxtp_2
XTAP_TAPCELL_ROW_37_658 VGND VPWR sky130_fd_sc_hd__tapvpwrvgnd_1
XFILLER_81_279 VGND VGND VPWR VPWR sky130_fd_sc_hd__fill_1
X_6863_ _6976_/CLK _6863_/D VGND VGND VPWR VPWR _6863_/Q sky130_fd_sc_hd__dfxtp_2
XTAP_TAPCELL_ROW_65_978 VGND VPWR sky130_fd_sc_hd__tapvpwrvgnd_1
XFILLER_22_302 VGND VGND VPWR VPWR sky130_fd_sc_hd__decap_3
XFILLER_22_324 VGND VGND VPWR VPWR sky130_fd_sc_hd__decap_3
XFILLER_34_162 VGND VGND VPWR VPWR sky130_fd_sc_hd__decap_3
XFILLER_50_611 VGND VGND VPWR VPWR sky130_fd_sc_hd__decap_3
X_6794_ clkload5/A _6794_/D VGND VGND VPWR VPWR _6794_/Q sky130_fd_sc_hd__dfxtp_2
X_5676_ _7344_/Q hold914/X _5697_/S VGND VGND VPWR VPWR _6688_/D sky130_fd_sc_hd__mux2_2
X_4627_ _4627_/A VGND VGND VPWR VPWR _4627_/Y sky130_fd_sc_hd__inv_2
XFILLER_1_206 VGND VGND VPWR VPWR sky130_fd_sc_hd__fill_2
X_7346_ _7355_/CLK _7346_/D _6626_/Y VGND VGND VPWR VPWR _7346_/Q sky130_fd_sc_hd__dfrtp_2
XTAP_TAPCELL_ROW_9_339 VGND VPWR sky130_fd_sc_hd__tapvpwrvgnd_1
XFILLER_104_635 VGND VGND VPWR VPWR sky130_fd_sc_hd__decap_3
XFILLER_1_228 VGND VGND VPWR VPWR sky130_fd_sc_hd__fill_2
XFILLER_89_335 VGND VGND VPWR VPWR sky130_fd_sc_hd__fill_1
XFILLER_89_346 VGND VGND VPWR VPWR sky130_fd_sc_hd__decap_3
X_7277_ _7363_/CLK _7277_/D _6557_/Y VGND VGND VPWR VPWR _7277_/Q sky130_fd_sc_hd__dfrtp_2
Xhold586 _6932_/Q VGND VGND VPWR VPWR _6932_/D sky130_fd_sc_hd__dlygate4sd3_1
Xhold597 _6856_/Q VGND VGND VPWR VPWR _6856_/D sky130_fd_sc_hd__dlygate4sd3_1
X_3509_ _5640_/B _3509_/B VGND VGND VPWR VPWR _3509_/Y sky130_fd_sc_hd__nor2_2
XFILLER_103_145 VGND VGND VPWR VPWR sky130_fd_sc_hd__decap_3
XFILLER_103_156 VGND VGND VPWR VPWR sky130_fd_sc_hd__decap_3
XFILLER_106_44 VGND VGND VPWR VPWR sky130_fd_sc_hd__decap_3
XFILLER_103_178 VGND VGND VPWR VPWR sky130_fd_sc_hd__decap_3
XTAP_TAPCELL_ROW_90_1270 VGND VPWR sky130_fd_sc_hd__tapvpwrvgnd_1
XFILLER_106_88 VGND VGND VPWR VPWR sky130_fd_sc_hd__decap_3
XFILLER_57_243 VGND VGND VPWR VPWR sky130_fd_sc_hd__decap_3
XFILLER_85_541 VGND VGND VPWR VPWR sky130_fd_sc_hd__decap_3
Xhold1220 _7359_/Q VGND VGND VPWR VPWR _5706_/A0 sky130_fd_sc_hd__dlygate4sd3_1
XFILLER_18_619 VGND VGND VPWR VPWR sky130_fd_sc_hd__decap_3
XFILLER_57_287 VGND VGND VPWR VPWR sky130_fd_sc_hd__decap_3
XFILLER_26_641 VGND VGND VPWR VPWR sky130_fd_sc_hd__decap_3
XFILLER_38_490 VGND VGND VPWR VPWR sky130_fd_sc_hd__decap_3
XFILLER_45_449 VGND VGND VPWR VPWR sky130_fd_sc_hd__fill_1
XFILLER_72_224 VGND VGND VPWR VPWR sky130_fd_sc_hd__decap_3
Xclkbuf_leaf_37_clk clkbuf_3_2__f_clk/X VGND VGND VPWR VPWR _7349_/CLK sky130_fd_sc_hd__clkbuf_16
XFILLER_53_460 VGND VGND VPWR VPWR sky130_fd_sc_hd__decap_3
XFILLER_60_419 VGND VGND VPWR VPWR sky130_fd_sc_hd__fill_1
XFILLER_13_313 VGND VGND VPWR VPWR sky130_fd_sc_hd__decap_3
XFILLER_25_162 VGND VGND VPWR VPWR sky130_fd_sc_hd__decap_3
XFILLER_25_184 VGND VGND VPWR VPWR sky130_fd_sc_hd__decap_3
XFILLER_40_110 VGND VGND VPWR VPWR sky130_fd_sc_hd__decap_3
XFILLER_41_644 VGND VGND VPWR VPWR sky130_fd_sc_hd__decap_3
XFILLER_21_390 VGND VGND VPWR VPWR sky130_fd_sc_hd__fill_2
XFILLER_40_187 VGND VGND VPWR VPWR sky130_fd_sc_hd__decap_3
XFILLER_31_40 VGND VGND VPWR VPWR sky130_fd_sc_hd__decap_3
XFILLER_5_523 VGND VGND VPWR VPWR sky130_fd_sc_hd__decap_3
XFILLER_107_440 VGND VGND VPWR VPWR sky130_fd_sc_hd__decap_3
XFILLER_31_84 VGND VGND VPWR VPWR sky130_fd_sc_hd__fill_2
XFILLER_5_556 VGND VGND VPWR VPWR sky130_fd_sc_hd__decap_3
XFILLER_5_567 VGND VGND VPWR VPWR sky130_fd_sc_hd__decap_3
XFILLER_0_272 VGND VGND VPWR VPWR sky130_fd_sc_hd__decap_3
XFILLER_48_221 VGND VGND VPWR VPWR sky130_fd_sc_hd__decap_3
XFILLER_88_390 VGND VGND VPWR VPWR sky130_fd_sc_hd__decap_3
XFILLER_48_265 VGND VGND VPWR VPWR sky130_fd_sc_hd__decap_3
XFILLER_91_511 VGND VGND VPWR VPWR sky130_fd_sc_hd__decap_3
XFILLER_17_641 VGND VGND VPWR VPWR sky130_fd_sc_hd__decap_3
XFILLER_36_449 VGND VGND VPWR VPWR sky130_fd_sc_hd__decap_3
XFILLER_56_81 VGND VGND VPWR VPWR sky130_fd_sc_hd__decap_3
XFILLER_63_213 VGND VGND VPWR VPWR sky130_fd_sc_hd__decap_3
XFILLER_91_544 VGND VGND VPWR VPWR sky130_fd_sc_hd__decap_3
Xclkbuf_leaf_28_clk clkbuf_3_6__f_clk/X VGND VGND VPWR VPWR _7361_/CLK sky130_fd_sc_hd__clkbuf_16
XFILLER_51_419 VGND VGND VPWR VPWR sky130_fd_sc_hd__decap_3
XFILLER_32_622 VGND VGND VPWR VPWR sky130_fd_sc_hd__decap_3
Xplace279 _3912_/A2 VGND VGND VPWR VPWR _3862_/A2 sky130_fd_sc_hd__buf_2
Xplace268 _3881_/B1 VGND VGND VPWR VPWR _3883_/B1 sky130_fd_sc_hd__buf_2
XTAP_TAPCELL_ROW_62_948 VGND VPWR sky130_fd_sc_hd__tapvpwrvgnd_1
XTAP_TAPCELL_ROW_34_628 VGND VPWR sky130_fd_sc_hd__tapvpwrvgnd_1
XTAP_TAPCELL_ROW_102_1406 VGND VPWR sky130_fd_sc_hd__tapvpwrvgnd_1
X_3860_ _3860_/A0 _3859_/X _3864_/S VGND VGND VPWR VPWR _7386_/D sky130_fd_sc_hd__mux2_2
XFILLER_31_154 VGND VGND VPWR VPWR sky130_fd_sc_hd__decap_3
X_3791_ _3775_/X _3790_/X _3896_/B1 VGND VGND VPWR VPWR _4961_/A sky130_fd_sc_hd__o21a_2
XFILLER_12_390 VGND VGND VPWR VPWR sky130_fd_sc_hd__decap_3
XFILLER_31_187 VGND VGND VPWR VPWR sky130_fd_sc_hd__decap_3
XFILLER_75_3 VGND VGND VPWR VPWR sky130_fd_sc_hd__decap_3
XTAP_TAPCELL_ROW_14_396 VGND VPWR sky130_fd_sc_hd__tapvpwrvgnd_1
X_7200_ _7357_/CLK _7200_/D _6480_/Y VGND VGND VPWR VPWR _7200_/Q sky130_fd_sc_hd__dfrtp_2
X_4412_ _4788_/B _4412_/B VGND VGND VPWR VPWR _4413_/A sky130_fd_sc_hd__or2_2
X_5392_ _5392_/A0 _4945_/X _5392_/S VGND VGND VPWR VPWR _7137_/D sky130_fd_sc_hd__mux2_2
X_7131_ _7352_/CLK _7131_/D _6411_/Y VGND VGND VPWR VPWR _7131_/Q sky130_fd_sc_hd__dfrtp_2
X_4343_ _4365_/C _4365_/A _4365_/B VGND VGND VPWR VPWR _4343_/X sky130_fd_sc_hd__and3b_2
XPHY_EDGE_ROW_99_Right_99 VGND VGND VPWR VPWR sky130_fd_sc_hd__decap_3
XFILLER_99_644 VGND VGND VPWR VPWR sky130_fd_sc_hd__decap_3
X_7062_ _7380_/CLK _7062_/D _6342_/Y VGND VGND VPWR VPWR _7062_/Q sky130_fd_sc_hd__dfrtp_2
X_4274_ _4376_/A _4376_/B _4376_/C _4273_/D VGND VGND VPWR VPWR _4274_/Y sky130_fd_sc_hd__o31ai_2
XTAP_TAPCELL_ROW_6_309 VGND VPWR sky130_fd_sc_hd__tapvpwrvgnd_1
XFILLER_98_165 VGND VGND VPWR VPWR sky130_fd_sc_hd__decap_3
XFILLER_101_638 VGND VGND VPWR VPWR sky130_fd_sc_hd__decap_3
XFILLER_86_338 VGND VGND VPWR VPWR sky130_fd_sc_hd__fill_2
XFILLER_79_390 VGND VGND VPWR VPWR sky130_fd_sc_hd__fill_2
XTAP_TAPCELL_ROW_68_1014 VGND VPWR sky130_fd_sc_hd__tapvpwrvgnd_1
XFILLER_36_29 VGND VGND VPWR VPWR sky130_fd_sc_hd__decap_3
XFILLER_39_287 VGND VGND VPWR VPWR sky130_fd_sc_hd__decap_3
XFILLER_39_298 VGND VGND VPWR VPWR sky130_fd_sc_hd__fill_1
XFILLER_54_224 VGND VGND VPWR VPWR sky130_fd_sc_hd__fill_2
XFILLER_82_533 VGND VGND VPWR VPWR sky130_fd_sc_hd__decap_3
XFILLER_82_544 VGND VGND VPWR VPWR sky130_fd_sc_hd__decap_3
XFILLER_94_393 VGND VGND VPWR VPWR sky130_fd_sc_hd__decap_3
Xclkbuf_leaf_19_clk clkbuf_3_6__f_clk/X VGND VGND VPWR VPWR _7392_/CLK sky130_fd_sc_hd__clkbuf_16
XFILLER_54_279 VGND VGND VPWR VPWR sky130_fd_sc_hd__decap_3
X_6915_ clkload9/A _6915_/D VGND VGND VPWR VPWR _6915_/Q sky130_fd_sc_hd__dfxtp_2
XFILLER_23_644 VGND VGND VPWR VPWR sky130_fd_sc_hd__decap_3
X_6846_ clkload7/A _6846_/D VGND VGND VPWR VPWR _6846_/Q sky130_fd_sc_hd__dfxtp_2
XFILLER_10_305 VGND VGND VPWR VPWR sky130_fd_sc_hd__decap_3
X_6777_ clkload4/A _6777_/D VGND VGND VPWR VPWR _6777_/Q sky130_fd_sc_hd__dfxtp_2
X_3989_ _7346_/Q _4530_/A0 _3989_/S VGND VGND VPWR VPWR _7346_/D sky130_fd_sc_hd__mux2_2
XFILLER_6_309 VGND VGND VPWR VPWR sky130_fd_sc_hd__fill_1
XTAP_TAPCELL_ROW_79_1143 VGND VPWR sky130_fd_sc_hd__tapvpwrvgnd_1
X_5659_ _5659_/A _5659_/B VGND VGND VPWR VPWR _5660_/D sky130_fd_sc_hd__nor2_2
XFILLER_104_421 VGND VGND VPWR VPWR sky130_fd_sc_hd__decap_3
XFILLER_2_526 VGND VGND VPWR VPWR sky130_fd_sc_hd__fill_1
XFILLER_2_548 VGND VGND VPWR VPWR sky130_fd_sc_hd__decap_3
X_7329_ _7364_/CLK _7329_/D _6609_/Y VGND VGND VPWR VPWR _7329_/Q sky130_fd_sc_hd__dfrtp_2
XFILLER_77_14 VGND VGND VPWR VPWR sky130_fd_sc_hd__fill_1
XFILLER_77_305 VGND VGND VPWR VPWR sky130_fd_sc_hd__decap_3
XFILLER_89_187 VGND VGND VPWR VPWR sky130_fd_sc_hd__decap_3
XFILLER_73_500 VGND VGND VPWR VPWR sky130_fd_sc_hd__fill_1
Xhold1050 _7391_/Q VGND VGND VPWR VPWR _3814_/A1 sky130_fd_sc_hd__dlygate4sd3_1
XFILLER_18_438 VGND VGND VPWR VPWR sky130_fd_sc_hd__decap_3
XFILLER_73_533 VGND VGND VPWR VPWR sky130_fd_sc_hd__decap_3
XFILLER_85_382 VGND VGND VPWR VPWR sky130_fd_sc_hd__decap_3
XFILLER_85_393 VGND VGND VPWR VPWR sky130_fd_sc_hd__decap_3
Xhold1061 _7232_/Q VGND VGND VPWR VPWR _5192_/A sky130_fd_sc_hd__dlygate4sd3_1
Xhold1072 _7388_/Q VGND VGND VPWR VPWR _3833_/A0 sky130_fd_sc_hd__dlygate4sd3_1
Xhold1083 _7286_/Q VGND VGND VPWR VPWR _4589_/A sky130_fd_sc_hd__dlygate4sd3_1
Xhold1094 _7332_/Q VGND VGND VPWR VPWR _4495_/A0 sky130_fd_sc_hd__dlygate4sd3_1
XFILLER_26_40 VGND VGND VPWR VPWR sky130_fd_sc_hd__decap_3
XFILLER_14_622 VGND VGND VPWR VPWR sky130_fd_sc_hd__decap_3
XFILLER_45_279 VGND VGND VPWR VPWR sky130_fd_sc_hd__fill_1
XFILLER_60_216 VGND VGND VPWR VPWR sky130_fd_sc_hd__decap_3
XFILLER_13_132 VGND VGND VPWR VPWR sky130_fd_sc_hd__decap_3
XFILLER_13_154 VGND VGND VPWR VPWR sky130_fd_sc_hd__decap_3
XFILLER_42_50 VGND VGND VPWR VPWR sky130_fd_sc_hd__decap_3
XFILLER_9_158 VGND VGND VPWR VPWR sky130_fd_sc_hd__decap_3
XFILLER_9_136 VGND VGND VPWR VPWR sky130_fd_sc_hd__fill_2
XFILLER_9_169 VGND VGND VPWR VPWR sky130_fd_sc_hd__decap_3
XTAP_TAPCELL_ROW_11_366 VGND VPWR sky130_fd_sc_hd__tapvpwrvgnd_1
XFILLER_5_353 VGND VGND VPWR VPWR sky130_fd_sc_hd__fill_1
XFILLER_107_281 VGND VGND VPWR VPWR sky130_fd_sc_hd__fill_1
XFILLER_1_570 VGND VGND VPWR VPWR sky130_fd_sc_hd__decap_3
XFILLER_68_349 VGND VGND VPWR VPWR sky130_fd_sc_hd__decap_3
XFILLER_95_124 VGND VGND VPWR VPWR sky130_fd_sc_hd__decap_3
XFILLER_64_500 VGND VGND VPWR VPWR sky130_fd_sc_hd__decap_3
XFILLER_36_224 VGND VGND VPWR VPWR sky130_fd_sc_hd__decap_3
XFILLER_36_235 VGND VGND VPWR VPWR sky130_fd_sc_hd__decap_3
XFILLER_76_371 VGND VGND VPWR VPWR sky130_fd_sc_hd__decap_3
XTAP_TAPCELL_ROW_19_455 VGND VPWR sky130_fd_sc_hd__tapvpwrvgnd_1
XFILLER_17_460 VGND VGND VPWR VPWR sky130_fd_sc_hd__fill_2
XFILLER_24_419 VGND VGND VPWR VPWR sky130_fd_sc_hd__fill_1
XFILLER_91_374 VGND VGND VPWR VPWR sky130_fd_sc_hd__decap_3
XFILLER_91_396 VGND VGND VPWR VPWR sky130_fd_sc_hd__decap_3
X_4961_ _4961_/A _5662_/C _4961_/C VGND VGND VPWR VPWR _4961_/X sky130_fd_sc_hd__or3_4
XTAP_TAPCELL_ROW_47_775 VGND VPWR sky130_fd_sc_hd__tapvpwrvgnd_1
X_6700_ clkload9/A _6700_/D VGND VGND VPWR VPWR _6700_/Q sky130_fd_sc_hd__dfxtp_2
X_4892_ _4884_/X _4886_/X _4887_/Y _4891_/X VGND VGND VPWR VPWR _5656_/B sky130_fd_sc_hd__a31o_2
X_3912_ _6905_/Q _3912_/A2 _3912_/B1 _6897_/Q VGND VGND VPWR VPWR _3912_/X sky130_fd_sc_hd__a22o_2
XFILLER_20_625 VGND VGND VPWR VPWR sky130_fd_sc_hd__decap_3
X_6631_ _6632_/A VGND VGND VPWR VPWR _6631_/Y sky130_fd_sc_hd__inv_2
X_3843_ _6699_/Q _3887_/A2 _3887_/B1 _6877_/Q _3842_/X VGND VGND VPWR VPWR _3843_/X
+ sky130_fd_sc_hd__a221o_2
X_6562_ _6594_/A VGND VGND VPWR VPWR _6562_/Y sky130_fd_sc_hd__inv_2
X_3774_ _6757_/Q _3884_/B1 _3912_/B1 _6769_/Q _3773_/X VGND VGND VPWR VPWR _3774_/X
+ sky130_fd_sc_hd__a221o_2
X_6493_ _6619_/A VGND VGND VPWR VPWR _6493_/Y sky130_fd_sc_hd__inv_2
Xclkbuf_leaf_8_clk clkbuf_leaf_9_clk/A VGND VGND VPWR VPWR _7071_/CLK sky130_fd_sc_hd__clkbuf_16
XFILLER_105_218 VGND VGND VPWR VPWR sky130_fd_sc_hd__decap_3
XFILLER_87_603 VGND VGND VPWR VPWR sky130_fd_sc_hd__fill_2
X_7114_ _7374_/CLK _7114_/D _6394_/Y VGND VGND VPWR VPWR _7114_/Q sky130_fd_sc_hd__dfrtp_2
Xoutput477 _5652_/Y VGND VGND VPWR VPWR alu_result_out[27] sky130_fd_sc_hd__clkdlybuf4s25_1
Xoutput466 _5662_/C VGND VGND VPWR VPWR alu_result_out[17] sky130_fd_sc_hd__clkdlybuf4s25_1
X_5375_ _5375_/A0 _4806_/X _5392_/S VGND VGND VPWR VPWR _7145_/D sky130_fd_sc_hd__mux2_2
XFILLER_99_452 VGND VGND VPWR VPWR sky130_fd_sc_hd__decap_3
XFILLER_101_413 VGND VGND VPWR VPWR sky130_fd_sc_hd__decap_3
XFILLER_59_327 VGND VGND VPWR VPWR sky130_fd_sc_hd__decap_3
XFILLER_86_113 VGND VGND VPWR VPWR sky130_fd_sc_hd__decap_3
Xoutput499 _3421_/B VGND VGND VPWR VPWR instruction_out[20] sky130_fd_sc_hd__clkdlybuf4s25_1
Xoutput488 _5651_/Y VGND VGND VPWR VPWR alu_result_out[8] sky130_fd_sc_hd__clkdlybuf4s25_1
X_4326_ _7013_/Q _4601_/S _4322_/X _4325_/X VGND VGND VPWR VPWR _4327_/B sky130_fd_sc_hd__a211o_2
XTAP_TAPCELL_ROW_74_1084 VGND VPWR sky130_fd_sc_hd__tapvpwrvgnd_1
XFILLER_101_446 VGND VGND VPWR VPWR sky130_fd_sc_hd__fill_2
XFILLER_87_647 VGND VGND VPWR VPWR sky130_fd_sc_hd__fill_1
X_7045_ _7392_/CLK _7045_/D _6325_/Y VGND VGND VPWR VPWR _7045_/Q sky130_fd_sc_hd__dfrtp_2
X_4257_ _4626_/B _4626_/C _4256_/C VGND VGND VPWR VPWR _4988_/B sky130_fd_sc_hd__a21oi_2
XFILLER_101_479 VGND VGND VPWR VPWR sky130_fd_sc_hd__decap_3
XFILLER_47_39 VGND VGND VPWR VPWR sky130_fd_sc_hd__fill_1
XFILLER_86_179 VGND VGND VPWR VPWR sky130_fd_sc_hd__decap_3
X_4188_ _7359_/Q _4261_/A2 _4187_/X _4347_/C1 VGND VGND VPWR VPWR _4188_/X sky130_fd_sc_hd__a211o_2
XFILLER_103_12 VGND VGND VPWR VPWR sky130_fd_sc_hd__decap_3
XFILLER_55_511 VGND VGND VPWR VPWR sky130_fd_sc_hd__decap_3
XFILLER_67_382 VGND VGND VPWR VPWR sky130_fd_sc_hd__decap_3
XFILLER_67_393 VGND VGND VPWR VPWR sky130_fd_sc_hd__decap_3
XFILLER_42_227 VGND VGND VPWR VPWR sky130_fd_sc_hd__decap_3
XFILLER_55_588 VGND VGND VPWR VPWR sky130_fd_sc_hd__decap_3
XFILLER_70_536 VGND VGND VPWR VPWR sky130_fd_sc_hd__decap_3
XFILLER_42_249 VGND VGND VPWR VPWR sky130_fd_sc_hd__decap_3
XFILLER_11_603 VGND VGND VPWR VPWR sky130_fd_sc_hd__decap_3
X_6829_ clkload7/A _6829_/D VGND VGND VPWR VPWR _6829_/Q sky130_fd_sc_hd__dfxtp_2
XFILLER_11_647 VGND VGND VPWR VPWR sky130_fd_sc_hd__fill_1
XFILLER_10_157 VGND VGND VPWR VPWR sky130_fd_sc_hd__decap_3
XFILLER_7_629 VGND VGND VPWR VPWR sky130_fd_sc_hd__decap_3
Xwire549 wire550/X VGND VGND VPWR VPWR wire549/X sky130_fd_sc_hd__buf_1
XFILLER_104_240 VGND VGND VPWR VPWR sky130_fd_sc_hd__decap_3
XFILLER_2_334 VGND VGND VPWR VPWR sky130_fd_sc_hd__decap_3
XFILLER_5_3 VGND VGND VPWR VPWR sky130_fd_sc_hd__decap_3
XFILLER_104_262 VGND VGND VPWR VPWR sky130_fd_sc_hd__decap_3
XFILLER_2_378 VGND VGND VPWR VPWR sky130_fd_sc_hd__decap_3
XFILLER_77_102 VGND VGND VPWR VPWR sky130_fd_sc_hd__fill_2
XFILLER_78_614 VGND VGND VPWR VPWR sky130_fd_sc_hd__decap_3
XFILLER_77_146 VGND VGND VPWR VPWR sky130_fd_sc_hd__decap_3
XFILLER_46_533 VGND VGND VPWR VPWR sky130_fd_sc_hd__decap_3
XFILLER_58_371 VGND VGND VPWR VPWR sky130_fd_sc_hd__decap_3
XFILLER_58_382 VGND VGND VPWR VPWR sky130_fd_sc_hd__decap_3
XFILLER_18_246 VGND VGND VPWR VPWR sky130_fd_sc_hd__decap_3
XFILLER_73_352 VGND VGND VPWR VPWR sky130_fd_sc_hd__decap_3
XFILLER_33_216 VGND VGND VPWR VPWR sky130_fd_sc_hd__decap_3
XFILLER_61_514 VGND VGND VPWR VPWR sky130_fd_sc_hd__decap_3
XFILLER_73_385 VGND VGND VPWR VPWR sky130_fd_sc_hd__decap_3
XFILLER_73_396 VGND VGND VPWR VPWR sky130_fd_sc_hd__decap_3
XTAP_TAPCELL_ROW_16_414 VGND VPWR sky130_fd_sc_hd__tapvpwrvgnd_1
XFILLER_61_569 VGND VGND VPWR VPWR sky130_fd_sc_hd__decap_3
XTAP_TAPCELL_ROW_44_745 VGND VPWR sky130_fd_sc_hd__tapvpwrvgnd_1
XFILLER_6_640 VGND VGND VPWR VPWR sky130_fd_sc_hd__decap_3
X_3490_ _7119_/Q _4341_/B1 _3489_/X _4248_/A VGND VGND VPWR VPWR _3490_/X sky130_fd_sc_hd__a211o_2
XFILLER_5_172 VGND VGND VPWR VPWR sky130_fd_sc_hd__decap_3
XFILLER_96_400 VGND VGND VPWR VPWR sky130_fd_sc_hd__decap_3
XFILLER_68_124 VGND VGND VPWR VPWR sky130_fd_sc_hd__decap_3
XFILLER_69_647 VGND VGND VPWR VPWR sky130_fd_sc_hd__fill_1
X_5091_ _6985_/Q _5068_/C _6986_/Q VGND VGND VPWR VPWR _5092_/B sky130_fd_sc_hd__a21o_2
X_4111_ _4109_/X _4111_/B VGND VGND VPWR VPWR _4845_/A sky130_fd_sc_hd__nand2b_2
XFILLER_68_168 VGND VGND VPWR VPWR sky130_fd_sc_hd__decap_3
X_4042_ _7341_/Q _3943_/S _4419_/B1 _7373_/Q _4429_/C1 VGND VGND VPWR VPWR _4042_/X
+ sky130_fd_sc_hd__a221o_2
XFILLER_37_533 VGND VGND VPWR VPWR sky130_fd_sc_hd__decap_3
XFILLER_49_382 VGND VGND VPWR VPWR sky130_fd_sc_hd__decap_3
XFILLER_84_639 VGND VGND VPWR VPWR sky130_fd_sc_hd__decap_3
XFILLER_83_149 VGND VGND VPWR VPWR sky130_fd_sc_hd__decap_3
XFILLER_24_227 VGND VGND VPWR VPWR sky130_fd_sc_hd__decap_3
XFILLER_52_536 VGND VGND VPWR VPWR sky130_fd_sc_hd__decap_3
XTAP_TAPCELL_ROW_108_1489 VGND VPWR sky130_fd_sc_hd__tapvpwrvgnd_1
XTAP_TAPCELL_ROW_108_1478 VGND VPWR sky130_fd_sc_hd__tapvpwrvgnd_1
X_4944_ _5010_/A _4944_/B _4944_/C VGND VGND VPWR VPWR _4944_/X sky130_fd_sc_hd__or3_2
XFILLER_20_411 VGND VGND VPWR VPWR sky130_fd_sc_hd__decap_3
XFILLER_32_293 VGND VGND VPWR VPWR sky130_fd_sc_hd__fill_1
X_4875_ _4842_/X _4871_/Y _4874_/X VGND VGND VPWR VPWR _5663_/C sky130_fd_sc_hd__a21bo_2
X_6614_ _6614_/A VGND VGND VPWR VPWR _6614_/Y sky130_fd_sc_hd__inv_2
X_3826_ _6731_/Q _3884_/B1 _3912_/B1 _6743_/Q _3825_/X VGND VGND VPWR VPWR _3826_/X
+ sky130_fd_sc_hd__a221o_2
XFILLER_20_477 VGND VGND VPWR VPWR sky130_fd_sc_hd__fill_2
XFILLER_20_488 VGND VGND VPWR VPWR sky130_fd_sc_hd__decap_3
X_6545_ _6546_/A VGND VGND VPWR VPWR _6545_/Y sky130_fd_sc_hd__inv_2
X_3757_ _3757_/A0 _3756_/X _4799_/A VGND VGND VPWR VPWR _7396_/D sky130_fd_sc_hd__mux2_2
XTAP_TAPCELL_ROW_76_1113 VGND VPWR sky130_fd_sc_hd__tapvpwrvgnd_1
XFILLER_106_527 VGND VGND VPWR VPWR sky130_fd_sc_hd__fill_2
X_6476_ _6669_/A VGND VGND VPWR VPWR _6476_/Y sky130_fd_sc_hd__inv_2
X_5427_ _5427_/A0 _5156_/X _5427_/S VGND VGND VPWR VPWR _7120_/D sky130_fd_sc_hd__mux2_2
XFILLER_87_411 VGND VGND VPWR VPWR sky130_fd_sc_hd__decap_3
X_5358_ _5358_/A0 _5156_/X _5358_/S VGND VGND VPWR VPWR _7152_/D sky130_fd_sc_hd__mux2_2
XFILLER_101_221 VGND VGND VPWR VPWR sky130_fd_sc_hd__decap_3
X_4309_ _7128_/Q _4351_/B1 _4307_/X _4308_/X VGND VGND VPWR VPWR _4311_/B sky130_fd_sc_hd__a211o_2
XFILLER_101_243 VGND VGND VPWR VPWR sky130_fd_sc_hd__decap_3
XFILLER_47_308 VGND VGND VPWR VPWR sky130_fd_sc_hd__decap_3
X_7028_ _7382_/CLK _7028_/D _6308_/Y VGND VGND VPWR VPWR _7028_/Q sky130_fd_sc_hd__dfrtp_2
XFILLER_101_287 VGND VGND VPWR VPWR sky130_fd_sc_hd__decap_3
XFILLER_28_533 VGND VGND VPWR VPWR sky130_fd_sc_hd__decap_3
XFILLER_74_127 VGND VGND VPWR VPWR sky130_fd_sc_hd__decap_3
XFILLER_55_352 VGND VGND VPWR VPWR sky130_fd_sc_hd__fill_1
XFILLER_67_190 VGND VGND VPWR VPWR sky130_fd_sc_hd__decap_3
XFILLER_74_26 VGND VGND VPWR VPWR sky130_fd_sc_hd__fill_2
XTAP_TAPCELL_ROW_87_1231 VGND VPWR sky130_fd_sc_hd__tapvpwrvgnd_1
XFILLER_15_205 VGND VGND VPWR VPWR sky130_fd_sc_hd__decap_3
XFILLER_43_503 VGND VGND VPWR VPWR sky130_fd_sc_hd__fill_1
XFILLER_55_374 VGND VGND VPWR VPWR sky130_fd_sc_hd__fill_1
XFILLER_82_160 VGND VGND VPWR VPWR sky130_fd_sc_hd__decap_3
XFILLER_55_396 VGND VGND VPWR VPWR sky130_fd_sc_hd__fill_2
XFILLER_70_377 VGND VGND VPWR VPWR sky130_fd_sc_hd__decap_3
XTAP_TAPCELL_ROW_41_704 VGND VPWR sky130_fd_sc_hd__tapvpwrvgnd_1
XFILLER_11_411 VGND VGND VPWR VPWR sky130_fd_sc_hd__decap_3
XFILLER_11_455 VGND VGND VPWR VPWR sky130_fd_sc_hd__decap_3
XTAP_TAPCELL_ROW_21_472 VGND VPWR sky130_fd_sc_hd__tapvpwrvgnd_1
XFILLER_99_12 VGND VGND VPWR VPWR sky130_fd_sc_hd__decap_3
XTAP_TAPCELL_ROW_98_1360 VGND VPWR sky130_fd_sc_hd__tapvpwrvgnd_1
XFILLER_3_632 VGND VGND VPWR VPWR sky130_fd_sc_hd__decap_3
XFILLER_2_153 VGND VGND VPWR VPWR sky130_fd_sc_hd__decap_3
XFILLER_2_186 VGND VGND VPWR VPWR sky130_fd_sc_hd__decap_3
XFILLER_66_628 VGND VGND VPWR VPWR sky130_fd_sc_hd__decap_3
XFILLER_19_511 VGND VGND VPWR VPWR sky130_fd_sc_hd__decap_3
XFILLER_93_447 VGND VGND VPWR VPWR sky130_fd_sc_hd__fill_1
Xsingle_cycle_cpu_578 VGND VGND VPWR VPWR instruction_out[1] single_cycle_cpu_578/LO
+ sky130_fd_sc_hd__conb_1
XFILLER_58_190 VGND VGND VPWR VPWR sky130_fd_sc_hd__decap_3
XFILLER_19_588 VGND VGND VPWR VPWR sky130_fd_sc_hd__decap_3
XFILLER_46_363 VGND VGND VPWR VPWR sky130_fd_sc_hd__fill_1
XFILLER_46_374 VGND VGND VPWR VPWR sky130_fd_sc_hd__decap_3
XTAP_TAPCELL_ROW_29_572 VGND VPWR sky130_fd_sc_hd__tapvpwrvgnd_1
XFILLER_34_536 VGND VGND VPWR VPWR sky130_fd_sc_hd__decap_3
XFILLER_34_558 VGND VGND VPWR VPWR sky130_fd_sc_hd__decap_3
XFILLER_61_322 VGND VGND VPWR VPWR sky130_fd_sc_hd__decap_3
XTAP_TAPCELL_ROW_57_892 VGND VPWR sky130_fd_sc_hd__tapvpwrvgnd_1
XFILLER_21_219 VGND VGND VPWR VPWR sky130_fd_sc_hd__decap_3
XFILLER_61_355 VGND VGND VPWR VPWR sky130_fd_sc_hd__fill_1
XFILLER_61_388 VGND VGND VPWR VPWR sky130_fd_sc_hd__decap_3
XFILLER_61_399 VGND VGND VPWR VPWR sky130_fd_sc_hd__decap_3
X_4660_ _4720_/A _4655_/X _4658_/A VGND VGND VPWR VPWR _4660_/X sky130_fd_sc_hd__a21bo_2
X_3611_ _5057_/A _3611_/B VGND VGND VPWR VPWR _3611_/Y sky130_fd_sc_hd__nor2_2
X_6330_ _6646_/A VGND VGND VPWR VPWR _6330_/Y sky130_fd_sc_hd__inv_2
X_4591_ _4591_/A _4595_/B VGND VGND VPWR VPWR _7285_/D sky130_fd_sc_hd__and2_2
Xhold905 _6718_/Q VGND VGND VPWR VPWR hold905/X sky130_fd_sc_hd__dlygate4sd3_1
Xhold916 _6707_/Q VGND VGND VPWR VPWR hold916/X sky130_fd_sc_hd__dlygate4sd3_1
Xhold927 _7018_/Q VGND VGND VPWR VPWR _5619_/A sky130_fd_sc_hd__dlygate4sd3_1
XFILLER_103_508 VGND VGND VPWR VPWR sky130_fd_sc_hd__decap_3
Xhold949 _6710_/Q VGND VGND VPWR VPWR hold949/X sky130_fd_sc_hd__dlygate4sd3_1
Xhold938 _7384_/Q VGND VGND VPWR VPWR hold938/X sky130_fd_sc_hd__dlygate4sd3_1
X_6261_ _6463_/A VGND VGND VPWR VPWR _6261_/Y sky130_fd_sc_hd__inv_2
X_3473_ _7312_/Q _3996_/S _4346_/B1 _7344_/Q _4338_/C1 VGND VGND VPWR VPWR _3473_/X
+ sky130_fd_sc_hd__a221o_2
XFILLER_88_208 VGND VGND VPWR VPWR sky130_fd_sc_hd__decap_3
XTAP_TAPCELL_ROW_71_1054 VGND VPWR sky130_fd_sc_hd__tapvpwrvgnd_1
XFILLER_57_617 VGND VGND VPWR VPWR sky130_fd_sc_hd__decap_3
XFILLER_56_105 VGND VGND VPWR VPWR sky130_fd_sc_hd__decap_3
XFILLER_56_138 VGND VGND VPWR VPWR sky130_fd_sc_hd__fill_2
X_5074_ _4852_/A _5073_/A _5073_/Y _4811_/C VGND VGND VPWR VPWR _5075_/C sky130_fd_sc_hd__a2bb2o_2
XFILLER_96_296 VGND VGND VPWR VPWR sky130_fd_sc_hd__decap_3
XFILLER_49_190 VGND VGND VPWR VPWR sky130_fd_sc_hd__decap_3
XFILLER_84_458 VGND VGND VPWR VPWR sky130_fd_sc_hd__decap_3
XFILLER_25_514 VGND VGND VPWR VPWR sky130_fd_sc_hd__fill_2
XFILLER_64_160 VGND VGND VPWR VPWR sky130_fd_sc_hd__decap_3
XFILLER_71_108 VGND VGND VPWR VPWR sky130_fd_sc_hd__decap_3
XFILLER_44_29 VGND VGND VPWR VPWR sky130_fd_sc_hd__decap_3
XFILLER_64_193 VGND VGND VPWR VPWR sky130_fd_sc_hd__decap_3
XFILLER_80_631 VGND VGND VPWR VPWR sky130_fd_sc_hd__decap_3
XFILLER_100_35 VGND VGND VPWR VPWR sky130_fd_sc_hd__decap_3
XFILLER_40_539 VGND VGND VPWR VPWR sky130_fd_sc_hd__decap_3
X_4927_ _4983_/A _4927_/B _5656_/C VGND VGND VPWR VPWR _4927_/X sky130_fd_sc_hd__or3_2
XTAP_TAPCELL_ROW_82_1183 VGND VPWR sky130_fd_sc_hd__tapvpwrvgnd_1
XTAP_TAPCELL_ROW_82_1172 VGND VPWR sky130_fd_sc_hd__tapvpwrvgnd_1
XFILLER_20_230 VGND VGND VPWR VPWR sky130_fd_sc_hd__decap_3
X_4858_ _6999_/Q _4858_/B VGND VGND VPWR VPWR _4870_/A sky130_fd_sc_hd__and2_2
X_3809_ _6836_/Q _3926_/B1 _3852_/B1 _6841_/Q VGND VGND VPWR VPWR _3809_/X sky130_fd_sc_hd__a22o_2
X_4789_ _5057_/A _4412_/B _4413_/A _4852_/A _4788_/Y VGND VGND VPWR VPWR _4789_/X
+ sky130_fd_sc_hd__o221a_2
XFILLER_106_302 VGND VGND VPWR VPWR sky130_fd_sc_hd__decap_3
X_6528_ _6636_/A VGND VGND VPWR VPWR _6528_/Y sky130_fd_sc_hd__inv_2
X_6459_ _6557_/A VGND VGND VPWR VPWR _6459_/Y sky130_fd_sc_hd__inv_2
XFILLER_79_208 VGND VGND VPWR VPWR sky130_fd_sc_hd__decap_3
XFILLER_0_635 VGND VGND VPWR VPWR sky130_fd_sc_hd__fill_1
XFILLER_47_116 VGND VGND VPWR VPWR sky130_fd_sc_hd__decap_3
XFILLER_48_628 VGND VGND VPWR VPWR sky130_fd_sc_hd__decap_3
XFILLER_75_414 VGND VGND VPWR VPWR sky130_fd_sc_hd__decap_3
XFILLER_47_149 VGND VGND VPWR VPWR sky130_fd_sc_hd__decap_3
XFILLER_18_85 VGND VGND VPWR VPWR sky130_fd_sc_hd__decap_3
XFILLER_28_374 VGND VGND VPWR VPWR sky130_fd_sc_hd__decap_3
XFILLER_90_417 VGND VGND VPWR VPWR sky130_fd_sc_hd__decap_3
XFILLER_55_193 VGND VGND VPWR VPWR sky130_fd_sc_hd__decap_3
XTAP_TAPCELL_ROW_26_531 VGND VPWR sky130_fd_sc_hd__tapvpwrvgnd_1
XFILLER_16_569 VGND VGND VPWR VPWR sky130_fd_sc_hd__fill_2
XFILLER_70_130 VGND VGND VPWR VPWR sky130_fd_sc_hd__decap_3
XFILLER_70_141 VGND VGND VPWR VPWR sky130_fd_sc_hd__decap_3
XTAP_TAPCELL_ROW_54_851 VGND VPWR sky130_fd_sc_hd__tapvpwrvgnd_1
XFILLER_11_230 VGND VGND VPWR VPWR sky130_fd_sc_hd__decap_3
XFILLER_11_263 VGND VGND VPWR VPWR sky130_fd_sc_hd__fill_1
XFILLER_11_296 VGND VGND VPWR VPWR sky130_fd_sc_hd__decap_3
XFILLER_7_234 VGND VGND VPWR VPWR sky130_fd_sc_hd__decap_3
XFILLER_7_267 VGND VGND VPWR VPWR sky130_fd_sc_hd__decap_3
XFILLER_3_440 VGND VGND VPWR VPWR sky130_fd_sc_hd__decap_3
XFILLER_98_539 VGND VGND VPWR VPWR sky130_fd_sc_hd__decap_3
XFILLER_39_617 VGND VGND VPWR VPWR sky130_fd_sc_hd__decap_3
XFILLER_78_230 VGND VGND VPWR VPWR sky130_fd_sc_hd__decap_3
XPHY_EDGE_ROW_0_Left_109 VGND VGND VPWR VPWR sky130_fd_sc_hd__decap_3
XFILLER_93_222 VGND VGND VPWR VPWR sky130_fd_sc_hd__fill_2
XFILLER_66_447 VGND VGND VPWR VPWR sky130_fd_sc_hd__decap_3
XFILLER_93_233 VGND VGND VPWR VPWR sky130_fd_sc_hd__decap_3
XFILLER_19_352 VGND VGND VPWR VPWR sky130_fd_sc_hd__decap_3
XFILLER_53_108 VGND VGND VPWR VPWR sky130_fd_sc_hd__decap_3
XFILLER_81_406 VGND VGND VPWR VPWR sky130_fd_sc_hd__decap_3
XFILLER_19_385 VGND VGND VPWR VPWR sky130_fd_sc_hd__decap_3
XFILLER_34_322 VGND VGND VPWR VPWR sky130_fd_sc_hd__fill_1
XFILLER_46_182 VGND VGND VPWR VPWR sky130_fd_sc_hd__decap_3
XFILLER_62_642 VGND VGND VPWR VPWR sky130_fd_sc_hd__fill_2
XFILLER_74_480 VGND VGND VPWR VPWR sky130_fd_sc_hd__decap_3
XTAP_TAPCELL_ROW_105_1437 VGND VPWR sky130_fd_sc_hd__tapvpwrvgnd_1
XFILLER_34_344 VGND VGND VPWR VPWR sky130_fd_sc_hd__decap_3
XFILLER_34_399 VGND VGND VPWR VPWR sky130_fd_sc_hd__decap_3
XFILLER_61_185 VGND VGND VPWR VPWR sky130_fd_sc_hd__decap_3
XFILLER_15_591 VGND VGND VPWR VPWR sky130_fd_sc_hd__decap_3
X_4712_ _7007_/Q _4738_/A VGND VGND VPWR VPWR _4731_/B sky130_fd_sc_hd__nand2_2
X_4643_ _4888_/A _4125_/X _4126_/A VGND VGND VPWR VPWR _4643_/Y sky130_fd_sc_hd__a21oi_2
X_7362_ _7362_/CLK _7362_/D _6642_/Y VGND VGND VPWR VPWR _7362_/Q sky130_fd_sc_hd__dfrtp_2
Xhold702 _6773_/Q VGND VGND VPWR VPWR _6773_/D sky130_fd_sc_hd__dlygate4sd3_1
X_7293_ _7364_/CLK _7293_/D _6573_/Y VGND VGND VPWR VPWR _7293_/Q sky130_fd_sc_hd__dfrtp_2
Xhold713 _6972_/Q VGND VGND VPWR VPWR _6972_/D sky130_fd_sc_hd__dlygate4sd3_1
Xhold724 _6873_/Q VGND VGND VPWR VPWR _6873_/D sky130_fd_sc_hd__dlygate4sd3_1
Xhold735 _6921_/Q VGND VGND VPWR VPWR _6921_/D sky130_fd_sc_hd__dlygate4sd3_1
Xhold746 _6744_/Q VGND VGND VPWR VPWR _6744_/D sky130_fd_sc_hd__dlygate4sd3_1
X_6313_ _6625_/A VGND VGND VPWR VPWR _6313_/Y sky130_fd_sc_hd__inv_2
X_3525_ _3525_/A _3525_/B VGND VGND VPWR VPWR _5114_/A sky130_fd_sc_hd__and2_2
XFILLER_103_305 VGND VGND VPWR VPWR sky130_fd_sc_hd__decap_3
XFILLER_89_539 VGND VGND VPWR VPWR sky130_fd_sc_hd__fill_1
Xhold757 _6855_/Q VGND VGND VPWR VPWR _6855_/D sky130_fd_sc_hd__dlygate4sd3_1
Xhold768 _6871_/Q VGND VGND VPWR VPWR _6871_/D sky130_fd_sc_hd__dlygate4sd3_1
Xhold779 _6862_/Q VGND VGND VPWR VPWR _6862_/D sky130_fd_sc_hd__dlygate4sd3_1
XFILLER_103_349 VGND VGND VPWR VPWR sky130_fd_sc_hd__decap_3
X_3456_ _7011_/Q _4599_/S _3448_/X _3455_/X VGND VGND VPWR VPWR _3456_/X sky130_fd_sc_hd__a211o_2
X_3387_ _3385_/Y _3386_/Y _4471_/S _3399_/B VGND VGND VPWR VPWR _3429_/B sky130_fd_sc_hd__a211o_2
XFILLER_97_561 VGND VGND VPWR VPWR sky130_fd_sc_hd__decap_3
XFILLER_57_414 VGND VGND VPWR VPWR sky130_fd_sc_hd__fill_1
XFILLER_57_436 VGND VGND VPWR VPWR sky130_fd_sc_hd__decap_3
XFILLER_69_296 VGND VGND VPWR VPWR sky130_fd_sc_hd__fill_1
X_5126_ _5126_/A0 _5125_/Y _5132_/S VGND VGND VPWR VPWR _7253_/D sky130_fd_sc_hd__mux2_2
XFILLER_57_447 VGND VGND VPWR VPWR sky130_fd_sc_hd__fill_1
X_5057_ _5057_/A _5057_/B VGND VGND VPWR VPWR _5057_/Y sky130_fd_sc_hd__nor2_2
XFILLER_37_160 VGND VGND VPWR VPWR sky130_fd_sc_hd__decap_3
XFILLER_44_108 VGND VGND VPWR VPWR sky130_fd_sc_hd__decap_3
XTAP_TAPCELL_ROW_84_1201 VGND VPWR sky130_fd_sc_hd__tapvpwrvgnd_1
XFILLER_25_322 VGND VGND VPWR VPWR sky130_fd_sc_hd__decap_3
XFILLER_53_620 VGND VGND VPWR VPWR sky130_fd_sc_hd__decap_3
XFILLER_52_130 VGND VGND VPWR VPWR sky130_fd_sc_hd__decap_3
XFILLER_52_141 VGND VGND VPWR VPWR sky130_fd_sc_hd__fill_2
XFILLER_52_152 VGND VGND VPWR VPWR sky130_fd_sc_hd__decap_3
XFILLER_80_461 VGND VGND VPWR VPWR sky130_fd_sc_hd__fill_2
XFILLER_25_388 VGND VGND VPWR VPWR sky130_fd_sc_hd__decap_3
XFILLER_52_174 VGND VGND VPWR VPWR sky130_fd_sc_hd__decap_3
XTAP_TAPCELL_ROW_51_821 VGND VPWR sky130_fd_sc_hd__tapvpwrvgnd_1
XTAP_TAPCELL_ROW_23_501 VGND VPWR sky130_fd_sc_hd__tapvpwrvgnd_1
XFILLER_4_215 VGND VGND VPWR VPWR sky130_fd_sc_hd__fill_1
XTAP_TAPCELL_ROW_95_1330 VGND VPWR sky130_fd_sc_hd__tapvpwrvgnd_1
XFILLER_20_20 VGND VGND VPWR VPWR sky130_fd_sc_hd__decap_3
XFILLER_4_226 VGND VGND VPWR VPWR sky130_fd_sc_hd__decap_3
XFILLER_20_75 VGND VGND VPWR VPWR sky130_fd_sc_hd__fill_2
XFILLER_4_259 VGND VGND VPWR VPWR sky130_fd_sc_hd__fill_1
XFILLER_0_443 VGND VGND VPWR VPWR sky130_fd_sc_hd__decap_3
XFILLER_96_57 VGND VGND VPWR VPWR sky130_fd_sc_hd__decap_3
XFILLER_102_382 VGND VGND VPWR VPWR sky130_fd_sc_hd__fill_2
XFILLER_48_414 VGND VGND VPWR VPWR sky130_fd_sc_hd__decap_3
XFILLER_75_211 VGND VGND VPWR VPWR sky130_fd_sc_hd__decap_3
XTAP_TAPCELL_ROW_59_910 VGND VPWR sky130_fd_sc_hd__tapvpwrvgnd_1
XFILLER_75_244 VGND VGND VPWR VPWR sky130_fd_sc_hd__decap_3
XFILLER_75_277 VGND VGND VPWR VPWR sky130_fd_sc_hd__decap_3
XTAP_TAPCELL_ROW_3_270 VGND VPWR sky130_fd_sc_hd__tapvpwrvgnd_1
XFILLER_44_631 VGND VGND VPWR VPWR sky130_fd_sc_hd__decap_3
XFILLER_56_480 VGND VGND VPWR VPWR sky130_fd_sc_hd__decap_3
XFILLER_63_439 VGND VGND VPWR VPWR sky130_fd_sc_hd__fill_1
Xplace406 _3488_/B VGND VGND VPWR VPWR _4532_/S sky130_fd_sc_hd__buf_2
Xplace417 _3956_/S VGND VGND VPWR VPWR _3945_/S sky130_fd_sc_hd__buf_2
Xplace428 _3368_/Y VGND VGND VPWR VPWR _3394_/A sky130_fd_sc_hd__buf_2
XFILLER_71_461 VGND VGND VPWR VPWR sky130_fd_sc_hd__decap_3
XFILLER_90_269 VGND VGND VPWR VPWR sky130_fd_sc_hd__decap_3
Xplace439 _5647_/A VGND VGND VPWR VPWR _5587_/B sky130_fd_sc_hd__buf_2
XFILLER_16_388 VGND VGND VPWR VPWR sky130_fd_sc_hd__decap_3
XFILLER_43_174 VGND VGND VPWR VPWR sky130_fd_sc_hd__decap_3
XFILLER_45_94 VGND VGND VPWR VPWR sky130_fd_sc_hd__fill_1
XFILLER_71_494 VGND VGND VPWR VPWR sky130_fd_sc_hd__decap_3
XFILLER_12_561 VGND VGND VPWR VPWR sky130_fd_sc_hd__decap_3
XFILLER_61_60 VGND VGND VPWR VPWR sky130_fd_sc_hd__decap_3
XFILLER_61_82 VGND VGND VPWR VPWR sky130_fd_sc_hd__decap_3
XFILLER_61_93 VGND VGND VPWR VPWR sky130_fd_sc_hd__decap_3
XTAP_TAPCELL_ROW_100_1389 VGND VPWR sky130_fd_sc_hd__tapvpwrvgnd_1
XFILLER_8_587 VGND VGND VPWR VPWR sky130_fd_sc_hd__fill_1
XFILLER_8_598 VGND VGND VPWR VPWR sky130_fd_sc_hd__decap_3
XANTENNA_4 reset VGND VGND VPWR VPWR sky130_fd_sc_hd__diode_2
XFILLER_6_66 VGND VGND VPWR VPWR sky130_fd_sc_hd__fill_1
XFILLER_6_88 VGND VGND VPWR VPWR sky130_fd_sc_hd__decap_3
X_3310_ _5118_/C _3519_/B _3383_/B _5129_/A VGND VGND VPWR VPWR _3310_/Y sky130_fd_sc_hd__a31oi_2
XFILLER_98_303 VGND VGND VPWR VPWR sky130_fd_sc_hd__decap_3
XFILLER_3_281 VGND VGND VPWR VPWR sky130_fd_sc_hd__fill_2
X_4290_ _4283_/X _4288_/X _5647_/B _4649_/A VGND VGND VPWR VPWR _4612_/B sky130_fd_sc_hd__a2bb2o_4
XFILLER_79_550 VGND VGND VPWR VPWR sky130_fd_sc_hd__decap_3
XFILLER_79_561 VGND VGND VPWR VPWR sky130_fd_sc_hd__decap_3
XFILLER_27_609 VGND VGND VPWR VPWR sky130_fd_sc_hd__decap_3
XFILLER_39_447 VGND VGND VPWR VPWR sky130_fd_sc_hd__fill_1
XFILLER_39_469 VGND VGND VPWR VPWR sky130_fd_sc_hd__decap_3
XFILLER_66_244 VGND VGND VPWR VPWR sky130_fd_sc_hd__decap_3
XFILLER_26_108 VGND VGND VPWR VPWR sky130_fd_sc_hd__decap_3
XFILLER_94_575 VGND VGND VPWR VPWR sky130_fd_sc_hd__decap_3
XFILLER_35_620 VGND VGND VPWR VPWR sky130_fd_sc_hd__decap_3
XFILLER_47_480 VGND VGND VPWR VPWR sky130_fd_sc_hd__decap_3
XFILLER_81_225 VGND VGND VPWR VPWR sky130_fd_sc_hd__decap_3
X_6931_ _7071_/CLK _6931_/D VGND VGND VPWR VPWR _6931_/Q sky130_fd_sc_hd__dfxtp_2
XFILLER_34_141 VGND VGND VPWR VPWR sky130_fd_sc_hd__decap_3
X_6862_ _6974_/CLK _6862_/D VGND VGND VPWR VPWR _6862_/Q sky130_fd_sc_hd__dfxtp_2
XTAP_TAPCELL_ROW_65_979 VGND VPWR sky130_fd_sc_hd__tapvpwrvgnd_1
XTAP_TAPCELL_ROW_37_659 VGND VPWR sky130_fd_sc_hd__tapvpwrvgnd_1
XFILLER_50_623 VGND VGND VPWR VPWR sky130_fd_sc_hd__decap_3
XFILLER_62_483 VGND VGND VPWR VPWR sky130_fd_sc_hd__decap_3
XFILLER_50_645 VGND VGND VPWR VPWR sky130_fd_sc_hd__decap_3
X_6793_ _6963_/CLK _6793_/D VGND VGND VPWR VPWR _6793_/Q sky130_fd_sc_hd__dfxtp_2
XFILLER_108_419 VGND VGND VPWR VPWR sky130_fd_sc_hd__fill_1
X_4626_ _4256_/C _4626_/B _4626_/C VGND VGND VPWR VPWR _4626_/X sky130_fd_sc_hd__and3b_2
X_7345_ _7376_/CLK _7345_/D _6625_/Y VGND VGND VPWR VPWR _7345_/Q sky130_fd_sc_hd__dfrtp_2
XFILLER_103_113 VGND VGND VPWR VPWR sky130_fd_sc_hd__fill_1
X_7276_ _7276_/CLK _7276_/D _6556_/Y VGND VGND VPWR VPWR _7276_/Q sky130_fd_sc_hd__dfrtp_2
Xhold587 _6964_/Q VGND VGND VPWR VPWR _6964_/D sky130_fd_sc_hd__dlygate4sd3_1
X_4488_ _4488_/A0 _7303_/Q _4488_/S VGND VGND VPWR VPWR _7335_/D sky130_fd_sc_hd__mux2_2
X_3508_ _3508_/A _3508_/B VGND VGND VPWR VPWR _3508_/Y sky130_fd_sc_hd__nor2_2
XFILLER_106_23 VGND VGND VPWR VPWR sky130_fd_sc_hd__decap_3
XFILLER_89_358 VGND VGND VPWR VPWR sky130_fd_sc_hd__decap_3
Xhold598 _6817_/Q VGND VGND VPWR VPWR _6817_/D sky130_fd_sc_hd__dlygate4sd3_1
X_3439_ _7282_/Q _4532_/S _3366_/X _7154_/Q _3438_/X VGND VGND VPWR VPWR _3439_/X
+ sky130_fd_sc_hd__a221o_2
XFILLER_106_56 VGND VGND VPWR VPWR sky130_fd_sc_hd__decap_3
XFILLER_57_211 VGND VGND VPWR VPWR sky130_fd_sc_hd__decap_3
XFILLER_85_520 VGND VGND VPWR VPWR sky130_fd_sc_hd__fill_1
XTAP_TAPCELL_ROW_90_1271 VGND VPWR sky130_fd_sc_hd__tapvpwrvgnd_1
XFILLER_85_553 VGND VGND VPWR VPWR sky130_fd_sc_hd__decap_3
Xhold1210 _7141_/Q VGND VGND VPWR VPWR _5383_/A0 sky130_fd_sc_hd__dlygate4sd3_1
Xhold1221 _7403_/Q VGND VGND VPWR VPWR _3693_/A0 sky130_fd_sc_hd__dlygate4sd3_1
XFILLER_57_277 VGND VGND VPWR VPWR sky130_fd_sc_hd__decap_3
XFILLER_72_203 VGND VGND VPWR VPWR sky130_fd_sc_hd__decap_3
XFILLER_85_564 VGND VGND VPWR VPWR sky130_fd_sc_hd__fill_2
XFILLER_85_575 VGND VGND VPWR VPWR sky130_fd_sc_hd__decap_3
XFILLER_17_119 VGND VGND VPWR VPWR sky130_fd_sc_hd__decap_3
XFILLER_26_620 VGND VGND VPWR VPWR sky130_fd_sc_hd__decap_3
XFILLER_38_480 VGND VGND VPWR VPWR sky130_fd_sc_hd__fill_1
XFILLER_45_439 VGND VGND VPWR VPWR sky130_fd_sc_hd__decap_3
XFILLER_72_236 VGND VGND VPWR VPWR sky130_fd_sc_hd__decap_3
XFILLER_72_247 VGND VGND VPWR VPWR sky130_fd_sc_hd__decap_3
XFILLER_72_269 VGND VGND VPWR VPWR sky130_fd_sc_hd__decap_3
XFILLER_82_26 VGND VGND VPWR VPWR sky130_fd_sc_hd__fill_2
XTAP_TAPCELL_ROW_0_240 VGND VPWR sky130_fd_sc_hd__tapvpwrvgnd_1
XFILLER_13_325 VGND VGND VPWR VPWR sky130_fd_sc_hd__decap_3
XFILLER_41_623 VGND VGND VPWR VPWR sky130_fd_sc_hd__decap_3
XFILLER_53_472 VGND VGND VPWR VPWR sky130_fd_sc_hd__fill_2
XFILLER_53_494 VGND VGND VPWR VPWR sky130_fd_sc_hd__decap_3
XFILLER_13_358 VGND VGND VPWR VPWR sky130_fd_sc_hd__decap_3
XFILLER_25_196 VGND VGND VPWR VPWR sky130_fd_sc_hd__decap_3
XFILLER_40_122 VGND VGND VPWR VPWR sky130_fd_sc_hd__decap_3
XFILLER_40_144 VGND VGND VPWR VPWR sky130_fd_sc_hd__decap_3
XFILLER_80_291 VGND VGND VPWR VPWR sky130_fd_sc_hd__fill_1
XFILLER_13_369 VGND VGND VPWR VPWR sky130_fd_sc_hd__decap_3
XFILLER_40_177 VGND VGND VPWR VPWR sky130_fd_sc_hd__fill_2
XFILLER_31_63 VGND VGND VPWR VPWR sky130_fd_sc_hd__decap_3
XFILLER_5_579 VGND VGND VPWR VPWR sky130_fd_sc_hd__decap_3
XFILLER_0_251 VGND VGND VPWR VPWR sky130_fd_sc_hd__fill_1
XFILLER_0_284 VGND VGND VPWR VPWR sky130_fd_sc_hd__fill_1
XFILLER_102_190 VGND VGND VPWR VPWR sky130_fd_sc_hd__fill_1
XFILLER_76_531 VGND VGND VPWR VPWR sky130_fd_sc_hd__fill_1
XFILLER_76_542 VGND VGND VPWR VPWR sky130_fd_sc_hd__decap_3
XFILLER_76_564 VGND VGND VPWR VPWR sky130_fd_sc_hd__decap_3
XFILLER_17_620 VGND VGND VPWR VPWR sky130_fd_sc_hd__decap_3
XFILLER_36_439 VGND VGND VPWR VPWR sky130_fd_sc_hd__fill_2
XFILLER_48_288 VGND VGND VPWR VPWR sky130_fd_sc_hd__decap_3
XFILLER_91_523 VGND VGND VPWR VPWR sky130_fd_sc_hd__decap_3
Xplace203 _3562_/B VGND VGND VPWR VPWR place203/X sky130_fd_sc_hd__buf_2
XFILLER_16_141 VGND VGND VPWR VPWR sky130_fd_sc_hd__decap_3
XFILLER_91_556 VGND VGND VPWR VPWR sky130_fd_sc_hd__decap_3
XFILLER_91_567 VGND VGND VPWR VPWR sky130_fd_sc_hd__decap_3
XFILLER_32_601 VGND VGND VPWR VPWR sky130_fd_sc_hd__decap_3
Xplace269 _3665_/X VGND VGND VPWR VPWR _3881_/B1 sky130_fd_sc_hd__buf_2
XTAP_TAPCELL_ROW_62_949 VGND VPWR sky130_fd_sc_hd__tapvpwrvgnd_1
XTAP_TAPCELL_ROW_34_629 VGND VPWR sky130_fd_sc_hd__tapvpwrvgnd_1
XTAP_TAPCELL_ROW_102_1407 VGND VPWR sky130_fd_sc_hd__tapvpwrvgnd_1
XFILLER_16_185 VGND VGND VPWR VPWR sky130_fd_sc_hd__decap_3
XFILLER_32_634 VGND VGND VPWR VPWR sky130_fd_sc_hd__decap_3
XFILLER_32_645 VGND VGND VPWR VPWR sky130_fd_sc_hd__decap_3
XFILLER_31_166 VGND VGND VPWR VPWR sky130_fd_sc_hd__fill_2
X_3790_ _3746_/X _3777_/X _3779_/X _5660_/A _3789_/X VGND VGND VPWR VPWR _3790_/X
+ sky130_fd_sc_hd__a221o_2
XTAP_TAPCELL_ROW_14_397 VGND VPWR sky130_fd_sc_hd__tapvpwrvgnd_1
X_4411_ _4411_/A _4411_/B VGND VGND VPWR VPWR _4412_/B sky130_fd_sc_hd__and2_2
X_7130_ _7280_/CLK _7130_/D _6410_/Y VGND VGND VPWR VPWR _7130_/Q sky130_fd_sc_hd__dfrtp_2
X_4342_ _7063_/Q _4305_/B _4460_/A VGND VGND VPWR VPWR _4365_/B sky130_fd_sc_hd__o21a_2
XFILLER_99_623 VGND VGND VPWR VPWR sky130_fd_sc_hd__decap_3
XFILLER_98_122 VGND VGND VPWR VPWR sky130_fd_sc_hd__decap_3
X_7061_ _7380_/CLK _7061_/D _6341_/Y VGND VGND VPWR VPWR _7061_/Q sky130_fd_sc_hd__dfrtp_2
X_4273_ _4376_/A _4376_/B _4376_/C _4273_/D VGND VGND VPWR VPWR _4273_/Y sky130_fd_sc_hd__nor4_1
XFILLER_98_144 VGND VGND VPWR VPWR sky130_fd_sc_hd__decap_3
XFILLER_100_116 VGND VGND VPWR VPWR sky130_fd_sc_hd__decap_3
XFILLER_101_617 VGND VGND VPWR VPWR sky130_fd_sc_hd__decap_3
XFILLER_98_188 VGND VGND VPWR VPWR sky130_fd_sc_hd__decap_3
.ends
