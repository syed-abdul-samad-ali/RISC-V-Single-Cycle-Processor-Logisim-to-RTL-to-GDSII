* NGSPICE file created from single_cycle_cpu.ext - technology: sky130A

* Black-box entry subcircuit for sky130_fd_sc_hd__decap_3 abstract view
.subckt sky130_fd_sc_hd__decap_3 VGND VNB VPB VPWR
.ends

* Black-box entry subcircuit for sky130_fd_sc_hd__dfxtp_2 abstract view
.subckt sky130_fd_sc_hd__dfxtp_2 CLK D VGND VNB VPB VPWR Q
.ends

* Black-box entry subcircuit for sky130_fd_sc_hd__tapvpwrvgnd_1 abstract view
.subckt sky130_fd_sc_hd__tapvpwrvgnd_1 VGND VPWR
.ends

* Black-box entry subcircuit for sky130_fd_sc_hd__fill_2 abstract view
.subckt sky130_fd_sc_hd__fill_2 VGND VNB VPB VPWR
.ends

* Black-box entry subcircuit for sky130_fd_sc_hd__fill_1 abstract view
.subckt sky130_fd_sc_hd__fill_1 VGND VNB VPB VPWR
.ends

* Black-box entry subcircuit for sky130_fd_sc_hd__mux2_2 abstract view
.subckt sky130_fd_sc_hd__mux2_2 A0 A1 S VGND VNB VPB VPWR X
.ends

* Black-box entry subcircuit for sky130_fd_sc_hd__nor4_2 abstract view
.subckt sky130_fd_sc_hd__nor4_2 A B C D VGND VNB VPB VPWR Y
.ends

* Black-box entry subcircuit for sky130_fd_sc_hd__or2_2 abstract view
.subckt sky130_fd_sc_hd__or2_2 A B VGND VNB VPB VPWR X
.ends

* Black-box entry subcircuit for sky130_fd_sc_hd__dfrtp_2 abstract view
.subckt sky130_fd_sc_hd__dfrtp_2 CLK D RESET_B VGND VNB VPB VPWR Q
.ends

* Black-box entry subcircuit for sky130_fd_sc_hd__dlygate4sd3_1 abstract view
.subckt sky130_fd_sc_hd__dlygate4sd3_1 A VGND VNB VPB VPWR X
.ends

* Black-box entry subcircuit for sky130_fd_sc_hd__nor3_2 abstract view
.subckt sky130_fd_sc_hd__nor3_2 A B C VGND VNB VPB VPWR Y
.ends

* Black-box entry subcircuit for sky130_fd_sc_hd__a221o_2 abstract view
.subckt sky130_fd_sc_hd__a221o_2 A1 A2 B1 B2 C1 VGND VNB VPB VPWR X
.ends

* Black-box entry subcircuit for sky130_fd_sc_hd__inv_2 abstract view
.subckt sky130_fd_sc_hd__inv_2 A VGND VNB VPB VPWR Y
.ends

* Black-box entry subcircuit for sky130_fd_sc_hd__a22o_2 abstract view
.subckt sky130_fd_sc_hd__a22o_2 A1 A2 B1 B2 VGND VNB VPB VPWR X
.ends

* Black-box entry subcircuit for sky130_fd_sc_hd__a211o_2 abstract view
.subckt sky130_fd_sc_hd__a211o_2 A1 A2 B1 C1 VGND VNB VPB VPWR X
.ends

* Black-box entry subcircuit for sky130_fd_sc_hd__and3_4 abstract view
.subckt sky130_fd_sc_hd__and3_4 A B C VGND VNB VPB VPWR X
.ends

* Black-box entry subcircuit for sky130_fd_sc_hd__a31o_2 abstract view
.subckt sky130_fd_sc_hd__a31o_2 A1 A2 A3 B1 VGND VNB VPB VPWR X
.ends

* Black-box entry subcircuit for sky130_fd_sc_hd__or4_4 abstract view
.subckt sky130_fd_sc_hd__or4_4 A B C D VGND VNB VPB VPWR X
.ends

* Black-box entry subcircuit for sky130_fd_sc_hd__nor2_2 abstract view
.subckt sky130_fd_sc_hd__nor2_2 A B VGND VNB VPB VPWR Y
.ends

* Black-box entry subcircuit for sky130_fd_sc_hd__o31a_2 abstract view
.subckt sky130_fd_sc_hd__o31a_2 A1 A2 A3 B1 VGND VNB VPB VPWR X
.ends

* Black-box entry subcircuit for sky130_fd_sc_hd__or3b_4 abstract view
.subckt sky130_fd_sc_hd__or3b_4 A B C_N VGND VNB VPB VPWR X
.ends

* Black-box entry subcircuit for sky130_fd_sc_hd__clkbuf_2 abstract view
.subckt sky130_fd_sc_hd__clkbuf_2 A VGND VNB VPB VPWR X
.ends

* Black-box entry subcircuit for sky130_fd_sc_hd__and2_2 abstract view
.subckt sky130_fd_sc_hd__and2_2 A B VGND VNB VPB VPWR X
.ends

* Black-box entry subcircuit for sky130_fd_sc_hd__xnor2_2 abstract view
.subckt sky130_fd_sc_hd__xnor2_2 A B VGND VNB VPB VPWR Y
.ends

* Black-box entry subcircuit for sky130_fd_sc_hd__o21ai_2 abstract view
.subckt sky130_fd_sc_hd__o21ai_2 A1 A2 B1 VGND VNB VPB VPWR Y
.ends

* Black-box entry subcircuit for sky130_fd_sc_hd__nand2_2 abstract view
.subckt sky130_fd_sc_hd__nand2_2 A B VGND VNB VPB VPWR Y
.ends

* Black-box entry subcircuit for sky130_fd_sc_hd__and3_2 abstract view
.subckt sky130_fd_sc_hd__and3_2 A B C VGND VNB VPB VPWR X
.ends

* Black-box entry subcircuit for sky130_fd_sc_hd__and2b_2 abstract view
.subckt sky130_fd_sc_hd__and2b_2 A_N B VGND VNB VPB VPWR X
.ends

* Black-box entry subcircuit for sky130_fd_sc_hd__a21o_2 abstract view
.subckt sky130_fd_sc_hd__a21o_2 A1 A2 B1 VGND VNB VPB VPWR X
.ends

* Black-box entry subcircuit for sky130_fd_sc_hd__or3_2 abstract view
.subckt sky130_fd_sc_hd__or3_2 A B C VGND VNB VPB VPWR X
.ends

* Black-box entry subcircuit for sky130_fd_sc_hd__buf_2 abstract view
.subckt sky130_fd_sc_hd__buf_2 A VGND VNB VPB VPWR X
.ends

* Black-box entry subcircuit for sky130_fd_sc_hd__diode_2 abstract view
.subckt sky130_fd_sc_hd__diode_2 DIODE VGND VNB VPB VPWR
.ends

* Black-box entry subcircuit for sky130_fd_sc_hd__a31oi_4 abstract view
.subckt sky130_fd_sc_hd__a31oi_4 A1 A2 A3 B1 VGND VNB VPB VPWR Y
.ends

* Black-box entry subcircuit for sky130_fd_sc_hd__o21a_2 abstract view
.subckt sky130_fd_sc_hd__o21a_2 A1 A2 B1 VGND VNB VPB VPWR X
.ends

* Black-box entry subcircuit for sky130_fd_sc_hd__o32a_2 abstract view
.subckt sky130_fd_sc_hd__o32a_2 A1 A2 A3 B1 B2 VGND VNB VPB VPWR X
.ends

* Black-box entry subcircuit for sky130_fd_sc_hd__clkdlybuf4s25_1 abstract view
.subckt sky130_fd_sc_hd__clkdlybuf4s25_1 A VGND VNB VPB VPWR X
.ends

* Black-box entry subcircuit for sky130_fd_sc_hd__or3b_2 abstract view
.subckt sky130_fd_sc_hd__or3b_2 A B C_N VGND VNB VPB VPWR X
.ends

* Black-box entry subcircuit for sky130_fd_sc_hd__clkbuf_16 abstract view
.subckt sky130_fd_sc_hd__clkbuf_16 A VGND VNB VPB VPWR X
.ends

* Black-box entry subcircuit for sky130_fd_sc_hd__o211ai_2 abstract view
.subckt sky130_fd_sc_hd__o211ai_2 A1 A2 B1 C1 VGND VNB VPB VPWR Y
.ends

* Black-box entry subcircuit for sky130_fd_sc_hd__o22a_2 abstract view
.subckt sky130_fd_sc_hd__o22a_2 A1 A2 B1 B2 VGND VNB VPB VPWR X
.ends

* Black-box entry subcircuit for sky130_fd_sc_hd__o221a_2 abstract view
.subckt sky130_fd_sc_hd__o221a_2 A1 A2 B1 B2 C1 VGND VNB VPB VPWR X
.ends

* Black-box entry subcircuit for sky130_fd_sc_hd__o311a_4 abstract view
.subckt sky130_fd_sc_hd__o311a_4 A1 A2 A3 B1 C1 VGND VNB VPB VPWR X
.ends

* Black-box entry subcircuit for sky130_fd_sc_hd__a211oi_4 abstract view
.subckt sky130_fd_sc_hd__a211oi_4 A1 A2 B1 C1 VGND VNB VPB VPWR Y
.ends

* Black-box entry subcircuit for sky130_fd_sc_hd__xor2_2 abstract view
.subckt sky130_fd_sc_hd__xor2_2 A B VGND VNB VPB VPWR X
.ends

* Black-box entry subcircuit for sky130_fd_sc_hd__or4b_2 abstract view
.subckt sky130_fd_sc_hd__or4b_2 A B C D_N VGND VNB VPB VPWR X
.ends

* Black-box entry subcircuit for sky130_fd_sc_hd__o2bb2a_2 abstract view
.subckt sky130_fd_sc_hd__o2bb2a_2 A1_N A2_N B1 B2 VGND VNB VPB VPWR X
.ends

* Black-box entry subcircuit for sky130_fd_sc_hd__nand3_2 abstract view
.subckt sky130_fd_sc_hd__nand3_2 A B C VGND VNB VPB VPWR Y
.ends

* Black-box entry subcircuit for sky130_fd_sc_hd__o31ai_4 abstract view
.subckt sky130_fd_sc_hd__o31ai_4 A1 A2 A3 B1 VGND VNB VPB VPWR Y
.ends

* Black-box entry subcircuit for sky130_fd_sc_hd__o21ba_2 abstract view
.subckt sky130_fd_sc_hd__o21ba_2 A1 A2 B1_N VGND VNB VPB VPWR X
.ends

* Black-box entry subcircuit for sky130_fd_sc_hd__or2_4 abstract view
.subckt sky130_fd_sc_hd__or2_4 A B VGND VNB VPB VPWR X
.ends

* Black-box entry subcircuit for sky130_fd_sc_hd__a211oi_2 abstract view
.subckt sky130_fd_sc_hd__a211oi_2 A1 A2 B1 C1 VGND VNB VPB VPWR Y
.ends

* Black-box entry subcircuit for sky130_fd_sc_hd__a21bo_2 abstract view
.subckt sky130_fd_sc_hd__a21bo_2 A1 A2 B1_N VGND VNB VPB VPWR X
.ends

* Black-box entry subcircuit for sky130_fd_sc_hd__a31oi_2 abstract view
.subckt sky130_fd_sc_hd__a31oi_2 A1 A2 A3 B1 VGND VNB VPB VPWR Y
.ends

* Black-box entry subcircuit for sky130_fd_sc_hd__a21oi_2 abstract view
.subckt sky130_fd_sc_hd__a21oi_2 A1 A2 B1 VGND VNB VPB VPWR Y
.ends

* Black-box entry subcircuit for sky130_fd_sc_hd__o211a_2 abstract view
.subckt sky130_fd_sc_hd__o211a_2 A1 A2 B1 C1 VGND VNB VPB VPWR X
.ends

* Black-box entry subcircuit for sky130_fd_sc_hd__or2b_2 abstract view
.subckt sky130_fd_sc_hd__or2b_2 A B_N VGND VNB VPB VPWR X
.ends

* Black-box entry subcircuit for sky130_fd_sc_hd__buf_1 abstract view
.subckt sky130_fd_sc_hd__buf_1 A VGND VNB VPB VPWR X
.ends

* Black-box entry subcircuit for sky130_fd_sc_hd__a32o_2 abstract view
.subckt sky130_fd_sc_hd__a32o_2 A1 A2 A3 B1 B2 VGND VNB VPB VPWR X
.ends

* Black-box entry subcircuit for sky130_fd_sc_hd__a2bb2o_2 abstract view
.subckt sky130_fd_sc_hd__a2bb2o_2 A1_N A2_N B1 B2 VGND VNB VPB VPWR X
.ends

* Black-box entry subcircuit for sky130_fd_sc_hd__xor2_4 abstract view
.subckt sky130_fd_sc_hd__xor2_4 A B VGND VNB VPB VPWR X
.ends

* Black-box entry subcircuit for sky130_fd_sc_hd__a21boi_2 abstract view
.subckt sky130_fd_sc_hd__a21boi_2 A1 A2 B1_N VGND VNB VPB VPWR Y
.ends

* Black-box entry subcircuit for sky130_fd_sc_hd__and2_4 abstract view
.subckt sky130_fd_sc_hd__and2_4 A B VGND VNB VPB VPWR X
.ends

* Black-box entry subcircuit for sky130_fd_sc_hd__o2111a_2 abstract view
.subckt sky130_fd_sc_hd__o2111a_2 A1 A2 B1 C1 D1 VGND VNB VPB VPWR X
.ends

* Black-box entry subcircuit for sky130_fd_sc_hd__and4_4 abstract view
.subckt sky130_fd_sc_hd__and4_4 A B C D VGND VNB VPB VPWR X
.ends

* Black-box entry subcircuit for sky130_fd_sc_hd__o31ai_2 abstract view
.subckt sky130_fd_sc_hd__o31ai_2 A1 A2 A3 B1 VGND VNB VPB VPWR Y
.ends

* Black-box entry subcircuit for sky130_fd_sc_hd__o311a_2 abstract view
.subckt sky130_fd_sc_hd__o311a_2 A1 A2 A3 B1 C1 VGND VNB VPB VPWR X
.ends

* Black-box entry subcircuit for sky130_fd_sc_hd__clkinv_2 abstract view
.subckt sky130_fd_sc_hd__clkinv_2 A VGND VNB VPB VPWR Y
.ends

* Black-box entry subcircuit for sky130_fd_sc_hd__conb_1 abstract view
.subckt sky130_fd_sc_hd__conb_1 VGND VNB VPB VPWR HI LO
.ends

* Black-box entry subcircuit for sky130_fd_sc_hd__a31o_4 abstract view
.subckt sky130_fd_sc_hd__a31o_4 A1 A2 A3 B1 VGND VNB VPB VPWR X
.ends

* Black-box entry subcircuit for sky130_fd_sc_hd__bufinv_16 abstract view
.subckt sky130_fd_sc_hd__bufinv_16 A VGND VNB VPB VPWR Y
.ends

* Black-box entry subcircuit for sky130_fd_sc_hd__clkbuf_1 abstract view
.subckt sky130_fd_sc_hd__clkbuf_1 A VGND VNB VPB VPWR X
.ends

* Black-box entry subcircuit for sky130_fd_sc_hd__inv_4 abstract view
.subckt sky130_fd_sc_hd__inv_4 A VGND VNB VPB VPWR Y
.ends

* Black-box entry subcircuit for sky130_fd_sc_hd__nor2_4 abstract view
.subckt sky130_fd_sc_hd__nor2_4 A B VGND VNB VPB VPWR Y
.ends

* Black-box entry subcircuit for sky130_fd_sc_hd__clkinvlp_4 abstract view
.subckt sky130_fd_sc_hd__clkinvlp_4 A VGND VNB VPB VPWR Y
.ends

* Black-box entry subcircuit for sky130_fd_sc_hd__inv_6 abstract view
.subckt sky130_fd_sc_hd__inv_6 A VGND VNB VPB VPWR Y
.ends

* Black-box entry subcircuit for sky130_fd_sc_hd__clkbuf_8 abstract view
.subckt sky130_fd_sc_hd__clkbuf_8 A VGND VNB VPB VPWR X
.ends

* Black-box entry subcircuit for sky130_fd_sc_hd__a221oi_2 abstract view
.subckt sky130_fd_sc_hd__a221oi_2 A1 A2 B1 B2 C1 VGND VNB VPB VPWR Y
.ends

* Black-box entry subcircuit for sky130_fd_sc_hd__and3b_2 abstract view
.subckt sky130_fd_sc_hd__and3b_2 A_N B C VGND VNB VPB VPWR X
.ends

* Black-box entry subcircuit for sky130_fd_sc_hd__nand3b_2 abstract view
.subckt sky130_fd_sc_hd__nand3b_2 A_N B C VGND VNB VPB VPWR Y
.ends

* Black-box entry subcircuit for sky130_fd_sc_hd__or3_4 abstract view
.subckt sky130_fd_sc_hd__or3_4 A B C VGND VNB VPB VPWR X
.ends

* Black-box entry subcircuit for sky130_fd_sc_hd__nor4b_2 abstract view
.subckt sky130_fd_sc_hd__nor4b_2 A B C D_N VGND VNB VPB VPWR Y
.ends

* Black-box entry subcircuit for sky130_fd_sc_hd__a21oi_4 abstract view
.subckt sky130_fd_sc_hd__a21oi_4 A1 A2 B1 VGND VNB VPB VPWR Y
.ends

* Black-box entry subcircuit for sky130_fd_sc_hd__o221ai_2 abstract view
.subckt sky130_fd_sc_hd__o221ai_2 A1 A2 B1 B2 C1 VGND VNB VPB VPWR Y
.ends

* Black-box entry subcircuit for sky130_fd_sc_hd__nand2b_4 abstract view
.subckt sky130_fd_sc_hd__nand2b_4 A_N B VGND VNB VPB VPWR Y
.ends

* Black-box entry subcircuit for sky130_fd_sc_hd__buf_4 abstract view
.subckt sky130_fd_sc_hd__buf_4 A VGND VNB VPB VPWR X
.ends

* Black-box entry subcircuit for sky130_fd_sc_hd__a2111o_2 abstract view
.subckt sky130_fd_sc_hd__a2111o_2 A1 A2 B1 C1 D1 VGND VNB VPB VPWR X
.ends

* Black-box entry subcircuit for sky130_fd_sc_hd__clkinv_8 abstract view
.subckt sky130_fd_sc_hd__clkinv_8 A VGND VNB VPB VPWR Y
.ends

* Black-box entry subcircuit for sky130_fd_sc_hd__mux4_2 abstract view
.subckt sky130_fd_sc_hd__mux4_2 A0 A1 A2 A3 S0 S1 VGND VNB VPB VPWR X
.ends

* Black-box entry subcircuit for sky130_fd_sc_hd__dfstp_2 abstract view
.subckt sky130_fd_sc_hd__dfstp_2 CLK D SET_B VGND VNB VPB VPWR Q
.ends

* Black-box entry subcircuit for sky130_fd_sc_hd__nor2b_2 abstract view
.subckt sky130_fd_sc_hd__nor2b_2 A B_N VGND VNB VPB VPWR Y
.ends

* Black-box entry subcircuit for sky130_fd_sc_hd__or4_2 abstract view
.subckt sky130_fd_sc_hd__or4_2 A B C D VGND VNB VPB VPWR X
.ends

* Black-box entry subcircuit for sky130_fd_sc_hd__nor2_1 abstract view
.subckt sky130_fd_sc_hd__nor2_1 A B VGND VNB VPB VPWR Y
.ends

* Black-box entry subcircuit for sky130_fd_sc_hd__and4_2 abstract view
.subckt sky130_fd_sc_hd__and4_2 A B C D VGND VNB VPB VPWR X
.ends

* Black-box entry subcircuit for sky130_fd_sc_hd__a311oi_2 abstract view
.subckt sky130_fd_sc_hd__a311oi_2 A1 A2 A3 B1 C1 VGND VNB VPB VPWR Y
.ends

* Black-box entry subcircuit for sky130_fd_sc_hd__o21a_4 abstract view
.subckt sky130_fd_sc_hd__o21a_4 A1 A2 B1 VGND VNB VPB VPWR X
.ends

* Black-box entry subcircuit for sky130_fd_sc_hd__nor4_1 abstract view
.subckt sky130_fd_sc_hd__nor4_1 A B C D VGND VNB VPB VPWR Y
.ends

* Black-box entry subcircuit for sky130_fd_sc_hd__a41o_2 abstract view
.subckt sky130_fd_sc_hd__a41o_2 A1 A2 A3 A4 B1 VGND VNB VPB VPWR X
.ends

* Black-box entry subcircuit for sky130_fd_sc_hd__nand4bb_2 abstract view
.subckt sky130_fd_sc_hd__nand4bb_2 A_N B_N C D VGND VNB VPB VPWR Y
.ends

* Black-box entry subcircuit for sky130_fd_sc_hd__o21bai_2 abstract view
.subckt sky130_fd_sc_hd__o21bai_2 A1 A2 B1_N VGND VNB VPB VPWR Y
.ends

* Black-box entry subcircuit for sky130_fd_sc_hd__nand2_4 abstract view
.subckt sky130_fd_sc_hd__nand2_4 A B VGND VNB VPB VPWR Y
.ends

* Black-box entry subcircuit for sky130_fd_sc_hd__mux2_4 abstract view
.subckt sky130_fd_sc_hd__mux2_4 A0 A1 S VGND VNB VPB VPWR X
.ends

* Black-box entry subcircuit for sky130_fd_sc_hd__o211ai_4 abstract view
.subckt sky130_fd_sc_hd__o211ai_4 A1 A2 B1 C1 VGND VNB VPB VPWR Y
.ends

* Black-box entry subcircuit for sky130_fd_sc_hd__and4bb_4 abstract view
.subckt sky130_fd_sc_hd__and4bb_4 A_N B_N C D VGND VNB VPB VPWR X
.ends

* Black-box entry subcircuit for sky130_fd_sc_hd__nand2b_2 abstract view
.subckt sky130_fd_sc_hd__nand2b_2 A_N B VGND VNB VPB VPWR Y
.ends

* Black-box entry subcircuit for sky130_fd_sc_hd__o211a_4 abstract view
.subckt sky130_fd_sc_hd__o211a_4 A1 A2 B1 C1 VGND VNB VPB VPWR X
.ends

* Black-box entry subcircuit for sky130_fd_sc_hd__or4b_4 abstract view
.subckt sky130_fd_sc_hd__or4b_4 A B C D_N VGND VNB VPB VPWR X
.ends

* Black-box entry subcircuit for sky130_fd_sc_hd__nor4bb_2 abstract view
.subckt sky130_fd_sc_hd__nor4bb_2 A B C_N D_N VGND VNB VPB VPWR Y
.ends

* Black-box entry subcircuit for sky130_fd_sc_hd__and4b_4 abstract view
.subckt sky130_fd_sc_hd__and4b_4 A_N B C D VGND VNB VPB VPWR X
.ends

* Black-box entry subcircuit for sky130_fd_sc_hd__nor3b_2 abstract view
.subckt sky130_fd_sc_hd__nor3b_2 A B C_N VGND VNB VPB VPWR Y
.ends

* Black-box entry subcircuit for sky130_fd_sc_hd__a22oi_2 abstract view
.subckt sky130_fd_sc_hd__a22oi_2 A1 A2 B1 B2 VGND VNB VPB VPWR Y
.ends

* Black-box entry subcircuit for sky130_fd_sc_hd__a311o_2 abstract view
.subckt sky130_fd_sc_hd__a311o_2 A1 A2 A3 B1 C1 VGND VNB VPB VPWR X
.ends

* Black-box entry subcircuit for sky130_fd_sc_hd__clkbuf_4 abstract view
.subckt sky130_fd_sc_hd__clkbuf_4 A VGND VNB VPB VPWR X
.ends

* Black-box entry subcircuit for sky130_fd_sc_hd__nand4b_4 abstract view
.subckt sky130_fd_sc_hd__nand4b_4 A_N B C D VGND VNB VPB VPWR Y
.ends

* Black-box entry subcircuit for sky130_fd_sc_hd__a2bb2o_4 abstract view
.subckt sky130_fd_sc_hd__a2bb2o_4 A1_N A2_N B1 B2 VGND VNB VPB VPWR X
.ends

.subckt single_cycle_cpu VGND VPWR alu_result_out[0] alu_result_out[10] alu_result_out[11]
+ alu_result_out[12] alu_result_out[13] alu_result_out[14] alu_result_out[15] alu_result_out[16]
+ alu_result_out[17] alu_result_out[18] alu_result_out[19] alu_result_out[1] alu_result_out[20]
+ alu_result_out[21] alu_result_out[22] alu_result_out[23] alu_result_out[24] alu_result_out[25]
+ alu_result_out[26] alu_result_out[27] alu_result_out[28] alu_result_out[29] alu_result_out[2]
+ alu_result_out[30] alu_result_out[31] alu_result_out[3] alu_result_out[4] alu_result_out[5]
+ alu_result_out[6] alu_result_out[7] alu_result_out[8] alu_result_out[9] clk instruction_out[0]
+ instruction_out[10] instruction_out[11] instruction_out[12] instruction_out[13]
+ instruction_out[14] instruction_out[15] instruction_out[16] instruction_out[17]
+ instruction_out[18] instruction_out[19] instruction_out[1] instruction_out[20] instruction_out[21]
+ instruction_out[22] instruction_out[23] instruction_out[24] instruction_out[25]
+ instruction_out[26] instruction_out[27] instruction_out[28] instruction_out[29]
+ instruction_out[2] instruction_out[30] instruction_out[31] instruction_out[3] instruction_out[4]
+ instruction_out[5] instruction_out[6] instruction_out[7] instruction_out[8] instruction_out[9]
+ pc_out[0] pc_out[10] pc_out[11] pc_out[12] pc_out[13] pc_out[14] pc_out[15] pc_out[16]
+ pc_out[17] pc_out[18] pc_out[19] pc_out[1] pc_out[20] pc_out[21] pc_out[22] pc_out[23]
+ pc_out[24] pc_out[25] pc_out[26] pc_out[27] pc_out[28] pc_out[29] pc_out[2] pc_out[30]
+ pc_out[31] pc_out[3] pc_out[4] pc_out[5] pc_out[6] pc_out[7] pc_out[8] pc_out[9]
+ reset
XFILLER_67_542 VGND VGND VPWR VPWR sky130_fd_sc_hd__decap_3
XFILLER_39_255 VGND VGND VPWR VPWR sky130_fd_sc_hd__decap_3
XFILLER_54_203 VGND VGND VPWR VPWR sky130_fd_sc_hd__decap_3
XFILLER_82_501 VGND VGND VPWR VPWR sky130_fd_sc_hd__decap_3
XFILLER_94_361 VGND VGND VPWR VPWR sky130_fd_sc_hd__decap_3
XFILLER_39_299 VGND VGND VPWR VPWR sky130_fd_sc_hd__decap_3
XFILLER_54_247 VGND VGND VPWR VPWR sky130_fd_sc_hd__decap_3
XFILLER_70_707 VGND VGND VPWR VPWR sky130_fd_sc_hd__decap_3
X_6914_ clkload9/A _6914_/D VGND VGND VPWR VPWR _6914_/Q sky130_fd_sc_hd__dfxtp_2
XTAP_TAPCELL_ROW_53_916 VGND VPWR sky130_fd_sc_hd__tapvpwrvgnd_1
XFILLER_22_100 VGND VGND VPWR VPWR sky130_fd_sc_hd__decap_3
XFILLER_23_612 VGND VGND VPWR VPWR sky130_fd_sc_hd__decap_3
XFILLER_23_623 VGND VGND VPWR VPWR sky130_fd_sc_hd__decap_3
XFILLER_23_656 VGND VGND VPWR VPWR sky130_fd_sc_hd__decap_3
XFILLER_52_29 VGND VGND VPWR VPWR sky130_fd_sc_hd__fill_2
X_6845_ _6983_/CLK _6845_/D VGND VGND VPWR VPWR _6845_/Q sky130_fd_sc_hd__dfxtp_2
XFILLER_22_144 VGND VGND VPWR VPWR sky130_fd_sc_hd__fill_1
XFILLER_50_464 VGND VGND VPWR VPWR sky130_fd_sc_hd__decap_3
X_6776_ _6968_/CLK _6776_/D VGND VGND VPWR VPWR _6776_/Q sky130_fd_sc_hd__dfxtp_2
XTAP_TAPCELL_ROW_33_673 VGND VPWR sky130_fd_sc_hd__tapvpwrvgnd_1
XFILLER_109_706 VGND VGND VPWR VPWR sky130_fd_sc_hd__decap_3
XFILLER_10_328 VGND VGND VPWR VPWR sky130_fd_sc_hd__decap_3
XFILLER_22_177 VGND VGND VPWR VPWR sky130_fd_sc_hd__decap_3
XFILLER_22_188 VGND VGND VPWR VPWR sky130_fd_sc_hd__fill_1
XFILLER_50_486 VGND VGND VPWR VPWR sky130_fd_sc_hd__decap_3
X_5727_ _7369_/Q _5727_/A1 _5735_/S VGND VGND VPWR VPWR _6713_/D sky130_fd_sc_hd__mux2_2
XFILLER_108_227 VGND VGND VPWR VPWR sky130_fd_sc_hd__decap_3
X_5658_ _5658_/A _5658_/B _5658_/C _5658_/D VGND VGND VPWR VPWR _5661_/C sky130_fd_sc_hd__nor4_2
XFILLER_117_11 VGND VGND VPWR VPWR sky130_fd_sc_hd__decap_3
X_5589_ _5589_/A _5595_/B VGND VGND VPWR VPWR _7033_/D sky130_fd_sc_hd__or2_2
XFILLER_117_44 VGND VGND VPWR VPWR sky130_fd_sc_hd__decap_3
XFILLER_2_516 VGND VGND VPWR VPWR sky130_fd_sc_hd__decap_3
XFILLER_89_100 VGND VGND VPWR VPWR sky130_fd_sc_hd__decap_3
XFILLER_89_122 VGND VGND VPWR VPWR sky130_fd_sc_hd__decap_3
X_7328_ _7360_/CLK _7328_/D _6608_/Y VGND VGND VPWR VPWR _7328_/Q sky130_fd_sc_hd__dfrtp_2
XFILLER_104_444 VGND VGND VPWR VPWR sky130_fd_sc_hd__decap_3
XFILLER_117_66 VGND VGND VPWR VPWR sky130_fd_sc_hd__decap_3
X_7259_ _7357_/CLK _7259_/D _6539_/Y VGND VGND VPWR VPWR _7259_/Q sky130_fd_sc_hd__dfrtp_2
XFILLER_104_477 VGND VGND VPWR VPWR sky130_fd_sc_hd__decap_3
XFILLER_117_99 VGND VGND VPWR VPWR sky130_fd_sc_hd__decap_3
XTAP_TAPCELL_ROW_5_321 VGND VPWR sky130_fd_sc_hd__tapvpwrvgnd_1
XFILLER_89_199 VGND VGND VPWR VPWR sky130_fd_sc_hd__decap_3
XFILLER_100_672 VGND VGND VPWR VPWR sky130_fd_sc_hd__decap_3
XFILLER_46_704 VGND VGND VPWR VPWR sky130_fd_sc_hd__decap_3
XFILLER_85_361 VGND VGND VPWR VPWR sky130_fd_sc_hd__decap_3
XFILLER_92_309 VGND VGND VPWR VPWR sky130_fd_sc_hd__decap_3
Xhold1040 _7392_/Q VGND VGND VPWR VPWR _3792_/A1 sky130_fd_sc_hd__dlygate4sd3_1
Xhold1051 _7051_/Q VGND VGND VPWR VPWR _5566_/A1 sky130_fd_sc_hd__dlygate4sd3_1
XFILLER_45_203 VGND VGND VPWR VPWR sky130_fd_sc_hd__decap_3
XFILLER_73_523 VGND VGND VPWR VPWR sky130_fd_sc_hd__decap_3
XFILLER_73_534 VGND VGND VPWR VPWR sky130_fd_sc_hd__decap_3
Xhold1062 _7019_/Q VGND VGND VPWR VPWR _5617_/A sky130_fd_sc_hd__dlygate4sd3_1
Xhold1073 _7023_/Q VGND VGND VPWR VPWR _5609_/A sky130_fd_sc_hd__dlygate4sd3_1
Xhold1084 _7396_/Q VGND VGND VPWR VPWR _3757_/A0 sky130_fd_sc_hd__dlygate4sd3_1
XFILLER_45_247 VGND VGND VPWR VPWR sky130_fd_sc_hd__decap_3
XFILLER_45_269 VGND VGND VPWR VPWR sky130_fd_sc_hd__fill_2
Xhold1095 _7196_/Q VGND VGND VPWR VPWR _5268_/A0 sky130_fd_sc_hd__dlygate4sd3_1
XFILLER_13_100 VGND VGND VPWR VPWR sky130_fd_sc_hd__fill_2
XFILLER_14_601 VGND VGND VPWR VPWR sky130_fd_sc_hd__decap_3
XFILLER_26_461 VGND VGND VPWR VPWR sky130_fd_sc_hd__decap_3
XFILLER_26_483 VGND VGND VPWR VPWR sky130_fd_sc_hd__decap_3
XFILLER_13_133 VGND VGND VPWR VPWR sky130_fd_sc_hd__decap_3
XFILLER_14_634 VGND VGND VPWR VPWR sky130_fd_sc_hd__decap_3
XFILLER_14_645 VGND VGND VPWR VPWR sky130_fd_sc_hd__decap_3
XFILLER_26_85 VGND VGND VPWR VPWR sky130_fd_sc_hd__decap_3
XFILLER_14_678 VGND VGND VPWR VPWR sky130_fd_sc_hd__decap_3
XFILLER_41_464 VGND VGND VPWR VPWR sky130_fd_sc_hd__fill_1
XFILLER_9_148 VGND VGND VPWR VPWR sky130_fd_sc_hd__fill_2
XFILLER_115_709 VGND VGND VPWR VPWR sky130_fd_sc_hd__decap_3
XFILLER_5_332 VGND VGND VPWR VPWR sky130_fd_sc_hd__decap_3
XFILLER_5_343 VGND VGND VPWR VPWR sky130_fd_sc_hd__decap_3
XFILLER_107_271 VGND VGND VPWR VPWR sky130_fd_sc_hd__decap_3
XFILLER_5_376 VGND VGND VPWR VPWR sky130_fd_sc_hd__decap_3
XFILLER_107_293 VGND VGND VPWR VPWR sky130_fd_sc_hd__decap_3
XFILLER_110_414 VGND VGND VPWR VPWR sky130_fd_sc_hd__decap_3
XFILLER_3_23 VGND VGND VPWR VPWR sky130_fd_sc_hd__fill_1
XFILLER_96_637 VGND VGND VPWR VPWR sky130_fd_sc_hd__decap_3
XFILLER_1_582 VGND VGND VPWR VPWR sky130_fd_sc_hd__decap_3
XFILLER_49_520 VGND VGND VPWR VPWR sky130_fd_sc_hd__decap_3
XFILLER_95_125 VGND VGND VPWR VPWR sky130_fd_sc_hd__decap_3
XFILLER_96_648 VGND VGND VPWR VPWR sky130_fd_sc_hd__decap_3
XFILLER_67_70 VGND VGND VPWR VPWR sky130_fd_sc_hd__decap_3
XFILLER_95_158 VGND VGND VPWR VPWR sky130_fd_sc_hd__decap_3
XFILLER_95_169 VGND VGND VPWR VPWR sky130_fd_sc_hd__decap_3
XTAP_TAPCELL_ROW_108_1605 VGND VPWR sky130_fd_sc_hd__tapvpwrvgnd_1
XFILLER_36_203 VGND VGND VPWR VPWR sky130_fd_sc_hd__decap_3
XFILLER_64_512 VGND VGND VPWR VPWR sky130_fd_sc_hd__decap_3
XFILLER_52_707 VGND VGND VPWR VPWR sky130_fd_sc_hd__decap_3
XFILLER_91_375 VGND VGND VPWR VPWR sky130_fd_sc_hd__decap_3
X_4960_ _4960_/A _4960_/B _4960_/C VGND VGND VPWR VPWR _4961_/C sky130_fd_sc_hd__nor3_2
XFILLER_44_291 VGND VGND VPWR VPWR sky130_fd_sc_hd__decap_3
X_4891_ _4970_/A1 _4126_/A _4889_/Y _4811_/C _4890_/Y VGND VGND VPWR VPWR _4891_/X
+ sky130_fd_sc_hd__a221o_2
X_3911_ _6690_/Q _3913_/B1 _3911_/B1 _6868_/Q _3910_/X VGND VGND VPWR VPWR _3911_/X
+ sky130_fd_sc_hd__a221o_2
XTAP_TAPCELL_ROW_67_1092 VGND VPWR sky130_fd_sc_hd__tapvpwrvgnd_1
XFILLER_20_604 VGND VGND VPWR VPWR sky130_fd_sc_hd__decap_3
XFILLER_32_475 VGND VGND VPWR VPWR sky130_fd_sc_hd__fill_1
X_6630_ _6630_/A VGND VGND VPWR VPWR _6630_/Y sky130_fd_sc_hd__inv_2
X_3842_ _6925_/Q _3851_/A2 _3853_/A2 _6789_/Q VGND VGND VPWR VPWR _3842_/X sky130_fd_sc_hd__a22o_2
XFILLER_20_637 VGND VGND VPWR VPWR sky130_fd_sc_hd__decap_3
XFILLER_20_648 VGND VGND VPWR VPWR sky130_fd_sc_hd__decap_3
X_6561_ _6593_/A VGND VGND VPWR VPWR _6561_/Y sky130_fd_sc_hd__inv_2
X_3773_ _6775_/Q _3912_/A2 _3913_/A2 _6763_/Q VGND VGND VPWR VPWR _3773_/X sky130_fd_sc_hd__a22o_2
XTAP_TAPCELL_ROW_30_632 VGND VPWR sky130_fd_sc_hd__tapvpwrvgnd_1
XFILLER_9_671 VGND VGND VPWR VPWR sky130_fd_sc_hd__fill_1
XFILLER_118_525 VGND VGND VPWR VPWR sky130_fd_sc_hd__decap_3
XFILLER_118_536 VGND VGND VPWR VPWR sky130_fd_sc_hd__fill_2
X_6492_ _6556_/A VGND VGND VPWR VPWR _6492_/Y sky130_fd_sc_hd__inv_2
XTAP_TAPCELL_ROW_119_1756 VGND VPWR sky130_fd_sc_hd__tapvpwrvgnd_1
XTAP_TAPCELL_ROW_119_1745 VGND VPWR sky130_fd_sc_hd__tapvpwrvgnd_1
XFILLER_9_682 VGND VGND VPWR VPWR sky130_fd_sc_hd__decap_3
X_7113_ _7371_/CLK _7113_/D _6393_/Y VGND VGND VPWR VPWR _7113_/Q sky130_fd_sc_hd__dfrtp_2
X_4325_ _7354_/Q _4337_/B _4323_/X _4324_/X VGND VGND VPWR VPWR _4325_/X sky130_fd_sc_hd__a211o_2
XFILLER_99_442 VGND VGND VPWR VPWR sky130_fd_sc_hd__decap_3
XFILLER_86_103 VGND VGND VPWR VPWR sky130_fd_sc_hd__decap_3
XFILLER_86_114 VGND VGND VPWR VPWR sky130_fd_sc_hd__decap_3
XFILLER_87_637 VGND VGND VPWR VPWR sky130_fd_sc_hd__decap_3
XFILLER_99_486 VGND VGND VPWR VPWR sky130_fd_sc_hd__decap_3
XFILLER_99_464 VGND VGND VPWR VPWR sky130_fd_sc_hd__fill_1
XFILLER_86_147 VGND VGND VPWR VPWR sky130_fd_sc_hd__decap_3
X_7044_ _7396_/CLK _7044_/D _6324_/Y VGND VGND VPWR VPWR _7044_/Q sky130_fd_sc_hd__dfrtp_2
X_4256_ _4626_/B _4626_/C _4256_/C VGND VGND VPWR VPWR _4988_/A sky130_fd_sc_hd__and3_4
XFILLER_28_704 VGND VGND VPWR VPWR sky130_fd_sc_hd__decap_3
XFILLER_74_309 VGND VGND VPWR VPWR sky130_fd_sc_hd__decap_3
X_4187_ _7327_/Q _3952_/S _4233_/B1 _7295_/Q VGND VGND VPWR VPWR _4187_/X sky130_fd_sc_hd__a22o_2
XFILLER_27_225 VGND VGND VPWR VPWR sky130_fd_sc_hd__decap_3
XFILLER_67_372 VGND VGND VPWR VPWR sky130_fd_sc_hd__decap_3
XFILLER_103_57 VGND VGND VPWR VPWR sky130_fd_sc_hd__decap_3
XFILLER_55_567 VGND VGND VPWR VPWR sky130_fd_sc_hd__decap_3
XTAP_TAPCELL_ROW_38_732 VGND VPWR sky130_fd_sc_hd__tapvpwrvgnd_1
XFILLER_42_206 VGND VGND VPWR VPWR sky130_fd_sc_hd__decap_3
XFILLER_70_526 VGND VGND VPWR VPWR sky130_fd_sc_hd__fill_2
XFILLER_23_431 VGND VGND VPWR VPWR sky130_fd_sc_hd__decap_3
XFILLER_82_397 VGND VGND VPWR VPWR sky130_fd_sc_hd__decap_3
XFILLER_11_615 VGND VGND VPWR VPWR sky130_fd_sc_hd__fill_1
XFILLER_23_475 VGND VGND VPWR VPWR sky130_fd_sc_hd__decap_3
X_6828_ clkload3/A _6828_/D VGND VGND VPWR VPWR _6828_/Q sky130_fd_sc_hd__dfxtp_2
XFILLER_11_626 VGND VGND VPWR VPWR sky130_fd_sc_hd__decap_3
XFILLER_109_503 VGND VGND VPWR VPWR sky130_fd_sc_hd__fill_1
XFILLER_11_659 VGND VGND VPWR VPWR sky130_fd_sc_hd__decap_3
X_6759_ clkload6/A _6759_/D VGND VGND VPWR VPWR _6759_/Q sky130_fd_sc_hd__dfxtp_2
XFILLER_12_32 VGND VGND VPWR VPWR sky130_fd_sc_hd__decap_3
XTAP_TAPCELL_ROW_94_1439 VGND VPWR sky130_fd_sc_hd__tapvpwrvgnd_1
XTAP_TAPCELL_ROW_94_1428 VGND VPWR sky130_fd_sc_hd__tapvpwrvgnd_1
XFILLER_2_302 VGND VGND VPWR VPWR sky130_fd_sc_hd__decap_3
XFILLER_104_230 VGND VGND VPWR VPWR sky130_fd_sc_hd__decap_3
XFILLER_117_591 VGND VGND VPWR VPWR sky130_fd_sc_hd__decap_3
XFILLER_2_335 VGND VGND VPWR VPWR sky130_fd_sc_hd__decap_3
XFILLER_88_58 VGND VGND VPWR VPWR sky130_fd_sc_hd__decap_3
XFILLER_104_274 VGND VGND VPWR VPWR sky130_fd_sc_hd__decap_3
XFILLER_77_103 VGND VGND VPWR VPWR sky130_fd_sc_hd__decap_3
XFILLER_78_626 VGND VGND VPWR VPWR sky130_fd_sc_hd__decap_3
XFILLER_77_125 VGND VGND VPWR VPWR sky130_fd_sc_hd__decap_3
XFILLER_77_147 VGND VGND VPWR VPWR sky130_fd_sc_hd__decap_3
XFILLER_78_648 VGND VGND VPWR VPWR sky130_fd_sc_hd__decap_3
XFILLER_77_169 VGND VGND VPWR VPWR sky130_fd_sc_hd__decap_3
XFILLER_92_106 VGND VGND VPWR VPWR sky130_fd_sc_hd__decap_3
XFILLER_93_607 VGND VGND VPWR VPWR sky130_fd_sc_hd__decap_3
XFILLER_93_629 VGND VGND VPWR VPWR sky130_fd_sc_hd__decap_3
XFILLER_100_480 VGND VGND VPWR VPWR sky130_fd_sc_hd__decap_3
XFILLER_18_203 VGND VGND VPWR VPWR sky130_fd_sc_hd__fill_1
XFILLER_58_383 VGND VGND VPWR VPWR sky130_fd_sc_hd__decap_3
XFILLER_86_681 VGND VGND VPWR VPWR sky130_fd_sc_hd__decap_3
XFILLER_92_139 VGND VGND VPWR VPWR sky130_fd_sc_hd__fill_1
XFILLER_18_236 VGND VGND VPWR VPWR sky130_fd_sc_hd__decap_3
XFILLER_18_258 VGND VGND VPWR VPWR sky130_fd_sc_hd__decap_3
XFILLER_34_707 VGND VGND VPWR VPWR sky130_fd_sc_hd__decap_3
XFILLER_85_180 VGND VGND VPWR VPWR sky130_fd_sc_hd__decap_3
XFILLER_73_386 VGND VGND VPWR VPWR sky130_fd_sc_hd__decap_3
XFILLER_33_228 VGND VGND VPWR VPWR sky130_fd_sc_hd__decap_3
XFILLER_61_537 VGND VGND VPWR VPWR sky130_fd_sc_hd__decap_3
XFILLER_61_548 VGND VGND VPWR VPWR sky130_fd_sc_hd__decap_3
XFILLER_14_442 VGND VGND VPWR VPWR sky130_fd_sc_hd__decap_3
XTAP_TAPCELL_ROW_16_459 VGND VPWR sky130_fd_sc_hd__tapvpwrvgnd_1
XTAP_TAPCELL_ROW_103_1546 VGND VPWR sky130_fd_sc_hd__tapvpwrvgnd_1
XFILLER_14_475 VGND VGND VPWR VPWR sky130_fd_sc_hd__fill_1
XFILLER_10_681 VGND VGND VPWR VPWR sky130_fd_sc_hd__decap_3
XFILLER_5_140 VGND VGND VPWR VPWR sky130_fd_sc_hd__decap_3
XFILLER_6_663 VGND VGND VPWR VPWR sky130_fd_sc_hd__decap_3
XFILLER_115_517 VGND VGND VPWR VPWR sky130_fd_sc_hd__decap_3
XFILLER_6_696 VGND VGND VPWR VPWR sky130_fd_sc_hd__decap_3
XFILLER_111_712 VGND VGND VPWR VPWR sky130_fd_sc_hd__fill_2
XFILLER_69_626 VGND VGND VPWR VPWR sky130_fd_sc_hd__decap_3
XFILLER_96_401 VGND VGND VPWR VPWR sky130_fd_sc_hd__decap_3
XTAP_TAPCELL_ROW_114_1686 VGND VPWR sky130_fd_sc_hd__tapvpwrvgnd_1
XFILLER_110_200 VGND VGND VPWR VPWR sky130_fd_sc_hd__decap_3
XFILLER_68_136 VGND VGND VPWR VPWR sky130_fd_sc_hd__decap_3
XFILLER_69_659 VGND VGND VPWR VPWR sky130_fd_sc_hd__decap_3
XFILLER_78_91 VGND VGND VPWR VPWR sky130_fd_sc_hd__decap_3
XFILLER_96_445 VGND VGND VPWR VPWR sky130_fd_sc_hd__decap_3
X_5090_ _5103_/A1 _5083_/X _5085_/X _5089_/Y VGND VGND VPWR VPWR _5658_/C sky130_fd_sc_hd__a31o_2
X_4110_ _4376_/A _4141_/A _4141_/B _4142_/C VGND VGND VPWR VPWR _4111_/B sky130_fd_sc_hd__or4_4
XFILLER_56_309 VGND VGND VPWR VPWR sky130_fd_sc_hd__decap_3
XFILLER_68_147 VGND VGND VPWR VPWR sky130_fd_sc_hd__decap_3
XFILLER_83_106 VGND VGND VPWR VPWR sky130_fd_sc_hd__decap_3
X_4041_ _7245_/Q _4430_/A2 _4428_/B1 _7149_/Q VGND VGND VPWR VPWR _4041_/X sky130_fd_sc_hd__a22o_2
XFILLER_110_277 VGND VGND VPWR VPWR sky130_fd_sc_hd__fill_1
XFILLER_110_299 VGND VGND VPWR VPWR sky130_fd_sc_hd__fill_1
XTAP_TAPCELL_ROW_69_1121 VGND VPWR sky130_fd_sc_hd__tapvpwrvgnd_1
XFILLER_64_353 VGND VGND VPWR VPWR sky130_fd_sc_hd__decap_3
XFILLER_92_640 VGND VGND VPWR VPWR sky130_fd_sc_hd__decap_3
XFILLER_92_651 VGND VGND VPWR VPWR sky130_fd_sc_hd__decap_3
XFILLER_24_206 VGND VGND VPWR VPWR sky130_fd_sc_hd__decap_3
XFILLER_52_504 VGND VGND VPWR VPWR sky130_fd_sc_hd__decap_3
XFILLER_52_515 VGND VGND VPWR VPWR sky130_fd_sc_hd__decap_3
XFILLER_91_172 VGND VGND VPWR VPWR sky130_fd_sc_hd__decap_3
XFILLER_92_684 VGND VGND VPWR VPWR sky130_fd_sc_hd__decap_3
XFILLER_24_239 VGND VGND VPWR VPWR sky130_fd_sc_hd__fill_2
X_4943_ _4943_/A _4943_/B VGND VGND VPWR VPWR _4944_/C sky130_fd_sc_hd__nor2_2
XFILLER_32_283 VGND VGND VPWR VPWR sky130_fd_sc_hd__fill_2
XFILLER_60_581 VGND VGND VPWR VPWR sky130_fd_sc_hd__fill_1
X_6613_ _6613_/A VGND VGND VPWR VPWR _6613_/Y sky130_fd_sc_hd__inv_2
X_4874_ _4814_/A _4849_/Y _4872_/X _4873_/X VGND VGND VPWR VPWR _4874_/X sky130_fd_sc_hd__o31a_2
XFILLER_20_445 VGND VGND VPWR VPWR sky130_fd_sc_hd__decap_3
XFILLER_20_467 VGND VGND VPWR VPWR sky130_fd_sc_hd__decap_3
X_3825_ _6749_/Q _3912_/A2 _3913_/A2 _6737_/Q VGND VGND VPWR VPWR _3825_/X sky130_fd_sc_hd__a22o_2
XTAP_TAPCELL_ROW_43_790 VGND VPWR sky130_fd_sc_hd__tapvpwrvgnd_1
XFILLER_20_489 VGND VGND VPWR VPWR sky130_fd_sc_hd__decap_3
X_6544_ _6544_/A VGND VGND VPWR VPWR _6544_/Y sky130_fd_sc_hd__inv_2
X_3756_ _6798_/Q _3759_/A2 _3760_/B1 _6708_/Q _3755_/X VGND VGND VPWR VPWR _3756_/X
+ sky130_fd_sc_hd__a221o_2
XFILLER_106_506 VGND VGND VPWR VPWR sky130_fd_sc_hd__decap_3
X_6475_ _6638_/A VGND VGND VPWR VPWR _6475_/Y sky130_fd_sc_hd__inv_2
XFILLER_106_539 VGND VGND VPWR VPWR sky130_fd_sc_hd__decap_3
XFILLER_102_701 VGND VGND VPWR VPWR sky130_fd_sc_hd__decap_3
XFILLER_114_550 VGND VGND VPWR VPWR sky130_fd_sc_hd__fill_2
XFILLER_59_125 VGND VGND VPWR VPWR sky130_fd_sc_hd__decap_3
XFILLER_87_445 VGND VGND VPWR VPWR sky130_fd_sc_hd__decap_3
X_5288_ _5288_/A0 _3993_/X _5292_/S VGND VGND VPWR VPWR _7185_/D sky130_fd_sc_hd__mux2_2
X_4308_ _7192_/Q _4471_/S _4354_/B1 _7384_/Q VGND VGND VPWR VPWR _4308_/X sky130_fd_sc_hd__a22o_2
XFILLER_114_23 VGND VGND VPWR VPWR sky130_fd_sc_hd__decap_3
XFILLER_59_169 VGND VGND VPWR VPWR sky130_fd_sc_hd__fill_2
XFILLER_75_607 VGND VGND VPWR VPWR sky130_fd_sc_hd__decap_3
XFILLER_75_629 VGND VGND VPWR VPWR sky130_fd_sc_hd__decap_3
XFILLER_87_467 VGND VGND VPWR VPWR sky130_fd_sc_hd__decap_3
X_7027_ _7372_/CLK _7027_/D _6307_/Y VGND VGND VPWR VPWR _7027_/Q sky130_fd_sc_hd__dfrtp_2
X_4239_ _4628_/A _4629_/B VGND VGND VPWR VPWR _5018_/B sky130_fd_sc_hd__nor2_2
XFILLER_114_56 VGND VGND VPWR VPWR sky130_fd_sc_hd__decap_3
XFILLER_68_681 VGND VGND VPWR VPWR sky130_fd_sc_hd__decap_3
XFILLER_74_106 VGND VGND VPWR VPWR sky130_fd_sc_hd__decap_3
XFILLER_74_139 VGND VGND VPWR VPWR sky130_fd_sc_hd__fill_1
XFILLER_16_707 VGND VGND VPWR VPWR sky130_fd_sc_hd__decap_3
XFILLER_28_589 VGND VGND VPWR VPWR sky130_fd_sc_hd__decap_3
XFILLER_55_375 VGND VGND VPWR VPWR sky130_fd_sc_hd__decap_3
XFILLER_82_150 VGND VGND VPWR VPWR sky130_fd_sc_hd__decap_3
XFILLER_83_662 VGND VGND VPWR VPWR sky130_fd_sc_hd__decap_3
XFILLER_83_673 VGND VGND VPWR VPWR sky130_fd_sc_hd__decap_3
XFILLER_15_228 VGND VGND VPWR VPWR sky130_fd_sc_hd__decap_3
XFILLER_70_345 VGND VGND VPWR VPWR sky130_fd_sc_hd__decap_3
XFILLER_82_183 VGND VGND VPWR VPWR sky130_fd_sc_hd__decap_3
XFILLER_82_194 VGND VGND VPWR VPWR sky130_fd_sc_hd__fill_2
XFILLER_23_261 VGND VGND VPWR VPWR sky130_fd_sc_hd__fill_2
XTAP_TAPCELL_ROW_13_418 VGND VPWR sky130_fd_sc_hd__tapvpwrvgnd_1
XFILLER_11_467 VGND VGND VPWR VPWR sky130_fd_sc_hd__decap_3
XFILLER_7_449 VGND VGND VPWR VPWR sky130_fd_sc_hd__decap_3
XFILLER_109_399 VGND VGND VPWR VPWR sky130_fd_sc_hd__decap_3
XFILLER_3_600 VGND VGND VPWR VPWR sky130_fd_sc_hd__fill_1
XFILLER_99_57 VGND VGND VPWR VPWR sky130_fd_sc_hd__decap_3
XFILLER_3_644 VGND VGND VPWR VPWR sky130_fd_sc_hd__decap_3
XFILLER_105_561 VGND VGND VPWR VPWR sky130_fd_sc_hd__decap_3
XFILLER_3_688 VGND VGND VPWR VPWR sky130_fd_sc_hd__decap_3
XFILLER_105_594 VGND VGND VPWR VPWR sky130_fd_sc_hd__decap_3
XFILLER_38_309 VGND VGND VPWR VPWR sky130_fd_sc_hd__decap_3
XFILLER_48_61 VGND VGND VPWR VPWR sky130_fd_sc_hd__decap_3
XFILLER_65_128 VGND VGND VPWR VPWR sky130_fd_sc_hd__decap_3
XFILLER_66_629 VGND VGND VPWR VPWR sky130_fd_sc_hd__decap_3
XFILLER_46_320 VGND VGND VPWR VPWR sky130_fd_sc_hd__fill_2
XFILLER_74_651 VGND VGND VPWR VPWR sky130_fd_sc_hd__decap_3
XFILLER_0_57 VGND VGND VPWR VPWR sky130_fd_sc_hd__fill_2
XFILLER_19_589 VGND VGND VPWR VPWR sky130_fd_sc_hd__decap_3
XFILLER_74_684 VGND VGND VPWR VPWR sky130_fd_sc_hd__decap_3
XFILLER_80_109 VGND VGND VPWR VPWR sky130_fd_sc_hd__decap_3
XFILLER_73_172 VGND VGND VPWR VPWR sky130_fd_sc_hd__fill_1
XFILLER_64_93 VGND VGND VPWR VPWR sky130_fd_sc_hd__fill_2
XFILLER_14_283 VGND VGND VPWR VPWR sky130_fd_sc_hd__decap_3
XFILLER_30_710 VGND VGND VPWR VPWR sky130_fd_sc_hd__decap_3
XFILLER_61_389 VGND VGND VPWR VPWR sky130_fd_sc_hd__decap_3
XTAP_TAPCELL_ROW_64_1062 VGND VPWR sky130_fd_sc_hd__tapvpwrvgnd_1
XFILLER_80_70 VGND VGND VPWR VPWR sky130_fd_sc_hd__decap_3
X_3610_ _3610_/A _3610_/B VGND VGND VPWR VPWR _3610_/Y sky130_fd_sc_hd__nor2_2
XTAP_TAPCELL_ROW_40_760 VGND VPWR sky130_fd_sc_hd__tapvpwrvgnd_1
XPHY_EDGE_ROW_104_Right_104 VGND VGND VPWR VPWR sky130_fd_sc_hd__decap_3
X_3541_ _4376_/A _3541_/B _4460_/B VGND VGND VPWR VPWR _3541_/X sky130_fd_sc_hd__or3b_4
XTAP_TAPCELL_ROW_116_1704 VGND VPWR sky130_fd_sc_hd__tapvpwrvgnd_1
Xhold906 _6960_/Q VGND VGND VPWR VPWR _6960_/D sky130_fd_sc_hd__dlygate4sd3_1
Xhold917 _6974_/Q VGND VGND VPWR VPWR _6974_/D sky130_fd_sc_hd__dlygate4sd3_1
Xhold928 _6779_/Q VGND VGND VPWR VPWR _6779_/D sky130_fd_sc_hd__dlygate4sd3_1
Xhold939 _6894_/Q VGND VGND VPWR VPWR _6894_/D sky130_fd_sc_hd__dlygate4sd3_1
Xmax_cap669 _4200_/A VGND VGND VPWR VPWR _4950_/A sky130_fd_sc_hd__clkbuf_2
X_6260_ _6662_/A VGND VGND VPWR VPWR _6260_/Y sky130_fd_sc_hd__inv_2
X_3472_ _7216_/Q _4349_/B1 _4348_/B1 _7120_/Q VGND VGND VPWR VPWR _3472_/X sky130_fd_sc_hd__a22o_2
XFILLER_69_401 VGND VGND VPWR VPWR sky130_fd_sc_hd__decap_3
XFILLER_88_209 VGND VGND VPWR VPWR sky130_fd_sc_hd__decap_3
X_5211_ _5211_/A _5211_/B VGND VGND VPWR VPWR _7223_/D sky130_fd_sc_hd__and2_2
XFILLER_69_434 VGND VGND VPWR VPWR sky130_fd_sc_hd__decap_3
X_5142_ _5142_/A0 _3993_/X _5142_/S VGND VGND VPWR VPWR _7249_/D sky130_fd_sc_hd__mux2_2
XTAP_TAPCELL_ROW_75_1191 VGND VPWR sky130_fd_sc_hd__tapvpwrvgnd_1
XFILLER_111_542 VGND VGND VPWR VPWR sky130_fd_sc_hd__decap_3
XFILLER_111_564 VGND VGND VPWR VPWR sky130_fd_sc_hd__decap_3
XFILLER_69_456 VGND VGND VPWR VPWR sky130_fd_sc_hd__fill_1
XFILLER_69_478 VGND VGND VPWR VPWR sky130_fd_sc_hd__decap_3
XFILLER_96_253 VGND VGND VPWR VPWR sky130_fd_sc_hd__decap_3
XFILLER_111_597 VGND VGND VPWR VPWR sky130_fd_sc_hd__decap_3
XFILLER_57_629 VGND VGND VPWR VPWR sky130_fd_sc_hd__decap_3
X_5073_ _5073_/A _5073_/B VGND VGND VPWR VPWR _5073_/Y sky130_fd_sc_hd__xnor2_2
XFILLER_37_331 VGND VGND VPWR VPWR sky130_fd_sc_hd__decap_3
XFILLER_56_139 VGND VGND VPWR VPWR sky130_fd_sc_hd__fill_1
XFILLER_84_459 VGND VGND VPWR VPWR sky130_fd_sc_hd__decap_3
XFILLER_64_150 VGND VGND VPWR VPWR sky130_fd_sc_hd__decap_3
XFILLER_65_662 VGND VGND VPWR VPWR sky130_fd_sc_hd__decap_3
XFILLER_65_673 VGND VGND VPWR VPWR sky130_fd_sc_hd__decap_3
XTAP_TAPCELL_ROW_48_860 VGND VPWR sky130_fd_sc_hd__tapvpwrvgnd_1
XFILLER_52_312 VGND VGND VPWR VPWR sky130_fd_sc_hd__decap_3
XFILLER_64_183 VGND VGND VPWR VPWR sky130_fd_sc_hd__decap_3
XFILLER_80_621 VGND VGND VPWR VPWR sky130_fd_sc_hd__decap_3
XFILLER_92_492 VGND VGND VPWR VPWR sky130_fd_sc_hd__decap_3
XFILLER_40_507 VGND VGND VPWR VPWR sky130_fd_sc_hd__decap_3
XFILLER_80_654 VGND VGND VPWR VPWR sky130_fd_sc_hd__decap_3
XFILLER_80_687 VGND VGND VPWR VPWR sky130_fd_sc_hd__decap_3
XFILLER_52_389 VGND VGND VPWR VPWR sky130_fd_sc_hd__decap_3
X_4926_ _4948_/A _4920_/Y _4925_/X VGND VGND VPWR VPWR _4927_/C sky130_fd_sc_hd__o21ai_2
X_4857_ _4857_/A _5655_/D wire663/X VGND VGND VPWR VPWR _4857_/X sky130_fd_sc_hd__or3b_4
XFILLER_119_620 VGND VGND VPWR VPWR sky130_fd_sc_hd__decap_3
XFILLER_20_253 VGND VGND VPWR VPWR sky130_fd_sc_hd__fill_1
XFILLER_60_29 VGND VGND VPWR VPWR sky130_fd_sc_hd__decap_3
X_3808_ _6929_/Q _3886_/A2 _3886_/B1 _6793_/Q _3807_/X VGND VGND VPWR VPWR _3808_/X
+ sky130_fd_sc_hd__a221o_2
XFILLER_109_12 VGND VGND VPWR VPWR sky130_fd_sc_hd__decap_3
XFILLER_118_141 VGND VGND VPWR VPWR sky130_fd_sc_hd__decap_3
XFILLER_119_642 VGND VGND VPWR VPWR sky130_fd_sc_hd__fill_2
XFILLER_20_297 VGND VGND VPWR VPWR sky130_fd_sc_hd__decap_3
X_6527_ _6625_/A VGND VGND VPWR VPWR _6527_/Y sky130_fd_sc_hd__inv_2
X_4788_ _4788_/A _4788_/B VGND VGND VPWR VPWR _4788_/Y sky130_fd_sc_hd__nand2_2
XFILLER_109_45 VGND VGND VPWR VPWR sky130_fd_sc_hd__decap_3
XFILLER_118_174 VGND VGND VPWR VPWR sky130_fd_sc_hd__decap_3
X_3739_ _6936_/Q _3906_/A2 _3910_/B1 _6800_/Q VGND VGND VPWR VPWR _3739_/X sky130_fd_sc_hd__a22o_2
XFILLER_109_78 VGND VGND VPWR VPWR sky130_fd_sc_hd__decap_3
X_6458_ _6647_/A VGND VGND VPWR VPWR _6458_/Y sky130_fd_sc_hd__inv_2
XFILLER_0_603 VGND VGND VPWR VPWR sky130_fd_sc_hd__decap_3
XFILLER_88_710 VGND VGND VPWR VPWR sky130_fd_sc_hd__decap_3
X_6389_ _6650_/A VGND VGND VPWR VPWR _6389_/Y sky130_fd_sc_hd__inv_2
X_5409_ _5409_/A0 _5079_/X _5427_/S VGND VGND VPWR VPWR _7129_/D sky130_fd_sc_hd__mux2_2
XFILLER_102_531 VGND VGND VPWR VPWR sky130_fd_sc_hd__fill_1
XFILLER_87_220 VGND VGND VPWR VPWR sky130_fd_sc_hd__decap_3
XFILLER_0_669 VGND VGND VPWR VPWR sky130_fd_sc_hd__decap_3
XFILLER_102_542 VGND VGND VPWR VPWR sky130_fd_sc_hd__decap_3
XFILLER_87_231 VGND VGND VPWR VPWR sky130_fd_sc_hd__decap_3
XFILLER_47_128 VGND VGND VPWR VPWR sky130_fd_sc_hd__decap_3
XFILLER_48_629 VGND VGND VPWR VPWR sky130_fd_sc_hd__decap_3
XFILLER_87_264 VGND VGND VPWR VPWR sky130_fd_sc_hd__decap_3
XFILLER_56_640 VGND VGND VPWR VPWR sky130_fd_sc_hd__decap_3
XFILLER_56_651 VGND VGND VPWR VPWR sky130_fd_sc_hd__decap_3
XFILLER_16_504 VGND VGND VPWR VPWR sky130_fd_sc_hd__decap_3
XFILLER_16_515 VGND VGND VPWR VPWR sky130_fd_sc_hd__decap_3
XFILLER_28_353 VGND VGND VPWR VPWR sky130_fd_sc_hd__fill_2
XFILLER_56_684 VGND VGND VPWR VPWR sky130_fd_sc_hd__decap_3
XFILLER_71_610 VGND VGND VPWR VPWR sky130_fd_sc_hd__decap_3
XFILLER_18_97 VGND VGND VPWR VPWR sky130_fd_sc_hd__decap_3
XFILLER_28_386 VGND VGND VPWR VPWR sky130_fd_sc_hd__decap_3
XFILLER_43_323 VGND VGND VPWR VPWR sky130_fd_sc_hd__fill_2
XFILLER_55_172 VGND VGND VPWR VPWR sky130_fd_sc_hd__decap_3
XFILLER_71_632 VGND VGND VPWR VPWR sky130_fd_sc_hd__decap_3
XFILLER_71_665 VGND VGND VPWR VPWR sky130_fd_sc_hd__decap_3
XFILLER_71_676 VGND VGND VPWR VPWR sky130_fd_sc_hd__decap_3
XFILLER_12_710 VGND VGND VPWR VPWR sky130_fd_sc_hd__decap_3
XTAP_TAPCELL_ROW_26_587 VGND VPWR sky130_fd_sc_hd__tapvpwrvgnd_1
XTAP_TAPCELL_ROW_100_1505 VGND VPWR sky130_fd_sc_hd__tapvpwrvgnd_1
XFILLER_24_592 VGND VGND VPWR VPWR sky130_fd_sc_hd__decap_3
XFILLER_34_85 VGND VGND VPWR VPWR sky130_fd_sc_hd__decap_3
XFILLER_70_197 VGND VGND VPWR VPWR sky130_fd_sc_hd__decap_3
XFILLER_11_242 VGND VGND VPWR VPWR sky130_fd_sc_hd__decap_3
XFILLER_11_264 VGND VGND VPWR VPWR sky130_fd_sc_hd__decap_3
XFILLER_109_152 VGND VGND VPWR VPWR sky130_fd_sc_hd__decap_3
XFILLER_105_380 VGND VGND VPWR VPWR sky130_fd_sc_hd__decap_3
XFILLER_3_496 VGND VGND VPWR VPWR sky130_fd_sc_hd__decap_3
XTAP_TAPCELL_ROW_111_1645 VGND VPWR sky130_fd_sc_hd__tapvpwrvgnd_1
XFILLER_39_607 VGND VGND VPWR VPWR sky130_fd_sc_hd__decap_3
XFILLER_78_242 VGND VGND VPWR VPWR sky130_fd_sc_hd__decap_3
XFILLER_78_253 VGND VGND VPWR VPWR sky130_fd_sc_hd__decap_3
XFILLER_39_629 VGND VGND VPWR VPWR sky130_fd_sc_hd__decap_3
XFILLER_66_415 VGND VGND VPWR VPWR sky130_fd_sc_hd__decap_3
XFILLER_66_437 VGND VGND VPWR VPWR sky130_fd_sc_hd__decap_3
XFILLER_94_713 VGND VGND VPWR VPWR sky130_fd_sc_hd__fill_1
XFILLER_38_139 VGND VGND VPWR VPWR sky130_fd_sc_hd__fill_1
XFILLER_93_223 VGND VGND VPWR VPWR sky130_fd_sc_hd__fill_1
XFILLER_93_234 VGND VGND VPWR VPWR sky130_fd_sc_hd__decap_3
XFILLER_47_662 VGND VGND VPWR VPWR sky130_fd_sc_hd__decap_3
XFILLER_47_673 VGND VGND VPWR VPWR sky130_fd_sc_hd__decap_3
XFILLER_75_70 VGND VGND VPWR VPWR sky130_fd_sc_hd__decap_3
XFILLER_81_418 VGND VGND VPWR VPWR sky130_fd_sc_hd__decap_3
XFILLER_93_278 VGND VGND VPWR VPWR sky130_fd_sc_hd__fill_2
XFILLER_34_301 VGND VGND VPWR VPWR sky130_fd_sc_hd__decap_3
XFILLER_46_183 VGND VGND VPWR VPWR sky130_fd_sc_hd__decap_3
XFILLER_62_632 VGND VGND VPWR VPWR sky130_fd_sc_hd__decap_3
XFILLER_61_131 VGND VGND VPWR VPWR sky130_fd_sc_hd__decap_3
XFILLER_62_654 VGND VGND VPWR VPWR sky130_fd_sc_hd__decap_3
XFILLER_15_581 VGND VGND VPWR VPWR sky130_fd_sc_hd__decap_3
XFILLER_22_529 VGND VGND VPWR VPWR sky130_fd_sc_hd__decap_3
XFILLER_61_164 VGND VGND VPWR VPWR sky130_fd_sc_hd__decap_3
XFILLER_61_175 VGND VGND VPWR VPWR sky130_fd_sc_hd__decap_3
XFILLER_62_687 VGND VGND VPWR VPWR sky130_fd_sc_hd__decap_3
XFILLER_61_197 VGND VGND VPWR VPWR sky130_fd_sc_hd__fill_2
XFILLER_91_80 VGND VGND VPWR VPWR sky130_fd_sc_hd__decap_3
X_4711_ _7005_/Q _7006_/Q _4775_/A VGND VGND VPWR VPWR _4738_/A sky130_fd_sc_hd__and3_2
XFILLER_30_562 VGND VGND VPWR VPWR sky130_fd_sc_hd__fill_2
XFILLER_30_573 VGND VGND VPWR VPWR sky130_fd_sc_hd__decap_3
X_4642_ _4207_/A _4642_/B VGND VGND VPWR VPWR _4888_/A sky130_fd_sc_hd__and2b_2
XFILLER_30_595 VGND VGND VPWR VPWR sky130_fd_sc_hd__decap_3
XFILLER_116_601 VGND VGND VPWR VPWR sky130_fd_sc_hd__decap_3
X_7361_ _7362_/CLK _7361_/D _6641_/Y VGND VGND VPWR VPWR _7361_/Q sky130_fd_sc_hd__dfrtp_2
Xhold703 _6786_/Q VGND VGND VPWR VPWR _6786_/D sky130_fd_sc_hd__dlygate4sd3_1
X_4573_ _4573_/A _4577_/B VGND VGND VPWR VPWR _7294_/D sky130_fd_sc_hd__and2_2
XTAP_TAPCELL_ROW_77_1220 VGND VPWR sky130_fd_sc_hd__tapvpwrvgnd_1
XFILLER_116_634 VGND VGND VPWR VPWR sky130_fd_sc_hd__decap_3
XFILLER_116_645 VGND VGND VPWR VPWR sky130_fd_sc_hd__decap_3
X_7292_ _7360_/CLK _7292_/D _6572_/Y VGND VGND VPWR VPWR _7292_/Q sky130_fd_sc_hd__dfrtp_2
Xhold714 _6742_/Q VGND VGND VPWR VPWR _6742_/D sky130_fd_sc_hd__dlygate4sd3_1
Xhold725 _6721_/Q VGND VGND VPWR VPWR _6721_/D sky130_fd_sc_hd__dlygate4sd3_1
Xhold736 _6886_/Q VGND VGND VPWR VPWR _6886_/D sky130_fd_sc_hd__dlygate4sd3_1
X_6312_ _6563_/A VGND VGND VPWR VPWR _6312_/Y sky130_fd_sc_hd__inv_2
XFILLER_116_678 VGND VGND VPWR VPWR sky130_fd_sc_hd__decap_3
Xhold747 _6777_/Q VGND VGND VPWR VPWR _6777_/D sky130_fd_sc_hd__dlygate4sd3_1
Xhold758 _6898_/Q VGND VGND VPWR VPWR _6898_/D sky130_fd_sc_hd__dlygate4sd3_1
Xhold769 _6782_/Q VGND VGND VPWR VPWR _6782_/D sky130_fd_sc_hd__dlygate4sd3_1
X_3455_ _7346_/Q _4337_/B _3454_/X VGND VGND VPWR VPWR _3455_/X sky130_fd_sc_hd__a21o_2
XFILLER_115_177 VGND VGND VPWR VPWR sky130_fd_sc_hd__fill_2
XFILLER_69_220 VGND VGND VPWR VPWR sky130_fd_sc_hd__decap_3
XFILLER_69_242 VGND VGND VPWR VPWR sky130_fd_sc_hd__decap_3
X_3386_ _5129_/A _3386_/B VGND VGND VPWR VPWR _3386_/Y sky130_fd_sc_hd__nand2_2
XFILLER_57_404 VGND VGND VPWR VPWR sky130_fd_sc_hd__decap_3
XFILLER_84_212 VGND VGND VPWR VPWR sky130_fd_sc_hd__decap_3
XFILLER_97_573 VGND VGND VPWR VPWR sky130_fd_sc_hd__decap_3
X_5125_ _5156_/S _5125_/B VGND VGND VPWR VPWR _5125_/Y sky130_fd_sc_hd__nand2_2
XFILLER_29_139 VGND VGND VPWR VPWR sky130_fd_sc_hd__decap_3
XFILLER_38_640 VGND VGND VPWR VPWR sky130_fd_sc_hd__decap_3
XFILLER_84_245 VGND VGND VPWR VPWR sky130_fd_sc_hd__decap_3
X_5056_ _3536_/B _4619_/B _5052_/X _5055_/X VGND VGND VPWR VPWR _5056_/X sky130_fd_sc_hd__o31a_2
XFILLER_38_651 VGND VGND VPWR VPWR sky130_fd_sc_hd__decap_3
XFILLER_84_256 VGND VGND VPWR VPWR sky130_fd_sc_hd__decap_3
XFILLER_84_278 VGND VGND VPWR VPWR sky130_fd_sc_hd__decap_3
XTAP_TAPCELL_ROW_88_1360 VGND VPWR sky130_fd_sc_hd__tapvpwrvgnd_1
XFILLER_38_684 VGND VGND VPWR VPWR sky130_fd_sc_hd__decap_3
XFILLER_53_632 VGND VGND VPWR VPWR sky130_fd_sc_hd__decap_3
XFILLER_111_24 VGND VGND VPWR VPWR sky130_fd_sc_hd__decap_3
XFILLER_37_194 VGND VGND VPWR VPWR sky130_fd_sc_hd__decap_3
XFILLER_52_153 VGND VGND VPWR VPWR sky130_fd_sc_hd__decap_3
XFILLER_53_665 VGND VGND VPWR VPWR sky130_fd_sc_hd__decap_3
XFILLER_53_676 VGND VGND VPWR VPWR sky130_fd_sc_hd__decap_3
XFILLER_80_451 VGND VGND VPWR VPWR sky130_fd_sc_hd__decap_3
XFILLER_111_57 VGND VGND VPWR VPWR sky130_fd_sc_hd__decap_3
XFILLER_25_389 VGND VGND VPWR VPWR sky130_fd_sc_hd__decap_3
XFILLER_40_315 VGND VGND VPWR VPWR sky130_fd_sc_hd__decap_3
XFILLER_52_186 VGND VGND VPWR VPWR sky130_fd_sc_hd__fill_2
XFILLER_52_197 VGND VGND VPWR VPWR sky130_fd_sc_hd__fill_1
XFILLER_71_39 VGND VGND VPWR VPWR sky130_fd_sc_hd__fill_1
X_4909_ _5647_/A _4909_/B _4909_/C VGND VGND VPWR VPWR _4910_/B sky130_fd_sc_hd__or3_2
XTAP_TAPCELL_ROW_23_546 VGND VPWR sky130_fd_sc_hd__tapvpwrvgnd_1
XTAP_TAPCELL_ROW_51_899 VGND VPWR sky130_fd_sc_hd__tapvpwrvgnd_1
XFILLER_107_601 VGND VGND VPWR VPWR sky130_fd_sc_hd__decap_3
XFILLER_107_623 VGND VGND VPWR VPWR sky130_fd_sc_hd__decap_3
XFILLER_119_461 VGND VGND VPWR VPWR sky130_fd_sc_hd__decap_3
XFILLER_5_706 VGND VGND VPWR VPWR sky130_fd_sc_hd__decap_3
XFILLER_106_122 VGND VGND VPWR VPWR sky130_fd_sc_hd__decap_3
XFILLER_107_656 VGND VGND VPWR VPWR sky130_fd_sc_hd__decap_3
XFILLER_119_483 VGND VGND VPWR VPWR sky130_fd_sc_hd__decap_3
XFILLER_20_21 VGND VGND VPWR VPWR sky130_fd_sc_hd__decap_3
XFILLER_20_32 VGND VGND VPWR VPWR sky130_fd_sc_hd__fill_2
XFILLER_106_166 VGND VGND VPWR VPWR sky130_fd_sc_hd__decap_3
XFILLER_0_411 VGND VGND VPWR VPWR sky130_fd_sc_hd__decap_3
XFILLER_106_188 VGND VGND VPWR VPWR sky130_fd_sc_hd__fill_1
XFILLER_0_455 VGND VGND VPWR VPWR sky130_fd_sc_hd__decap_3
XFILLER_0_477 VGND VGND VPWR VPWR sky130_fd_sc_hd__decap_3
XFILLER_76_713 VGND VGND VPWR VPWR sky130_fd_sc_hd__fill_1
XFILLER_88_584 VGND VGND VPWR VPWR sky130_fd_sc_hd__decap_3
XFILLER_29_63 VGND VGND VPWR VPWR sky130_fd_sc_hd__decap_3
XFILLER_75_223 VGND VGND VPWR VPWR sky130_fd_sc_hd__fill_1
XFILLER_75_234 VGND VGND VPWR VPWR sky130_fd_sc_hd__decap_3
XFILLER_28_150 VGND VGND VPWR VPWR sky130_fd_sc_hd__decap_3
XFILLER_29_662 VGND VGND VPWR VPWR sky130_fd_sc_hd__decap_3
XFILLER_29_673 VGND VGND VPWR VPWR sky130_fd_sc_hd__decap_3
XFILLER_63_407 VGND VGND VPWR VPWR sky130_fd_sc_hd__decap_3
XTAP_TAPCELL_ROW_59_999 VGND VPWR sky130_fd_sc_hd__tapvpwrvgnd_1
XFILLER_16_323 VGND VGND VPWR VPWR sky130_fd_sc_hd__decap_3
XFILLER_44_610 VGND VGND VPWR VPWR sky130_fd_sc_hd__decap_3
Xplace429 _3991_/A VGND VGND VPWR VPWR _5151_/A sky130_fd_sc_hd__buf_2
Xplace418 _3409_/X VGND VGND VPWR VPWR _4352_/B1 sky130_fd_sc_hd__buf_2
Xplace407 _3417_/X VGND VGND VPWR VPWR _4351_/A2 sky130_fd_sc_hd__buf_2
XTAP_TAPCELL_ROW_3_293 VGND VPWR sky130_fd_sc_hd__tapvpwrvgnd_1
XFILLER_44_643 VGND VGND VPWR VPWR sky130_fd_sc_hd__fill_1
XFILLER_44_654 VGND VGND VPWR VPWR sky130_fd_sc_hd__decap_3
XFILLER_43_175 VGND VGND VPWR VPWR sky130_fd_sc_hd__decap_3
XFILLER_44_687 VGND VGND VPWR VPWR sky130_fd_sc_hd__decap_3
XFILLER_31_337 VGND VGND VPWR VPWR sky130_fd_sc_hd__fill_1
XFILLER_31_348 VGND VGND VPWR VPWR sky130_fd_sc_hd__decap_3
XTAP_TAPCELL_ROW_61_1021 VGND VPWR sky130_fd_sc_hd__tapvpwrvgnd_1
XFILLER_101_90 VGND VGND VPWR VPWR sky130_fd_sc_hd__fill_2
XFILLER_84_9 VGND VGND VPWR VPWR sky130_fd_sc_hd__decap_3
XFILLER_8_522 VGND VGND VPWR VPWR sky130_fd_sc_hd__fill_1
XFILLER_117_409 VGND VGND VPWR VPWR sky130_fd_sc_hd__fill_2
XFILLER_12_584 VGND VGND VPWR VPWR sky130_fd_sc_hd__decap_3
XFILLER_12_595 VGND VGND VPWR VPWR sky130_fd_sc_hd__decap_3
XFILLER_61_94 VGND VGND VPWR VPWR sky130_fd_sc_hd__fill_2
XFILLER_8_533 VGND VGND VPWR VPWR sky130_fd_sc_hd__fill_1
XFILLER_8_566 VGND VGND VPWR VPWR sky130_fd_sc_hd__decap_3
XANTENNA_5 _4371_/A VGND VGND VPWR VPWR sky130_fd_sc_hd__diode_2
XFILLER_113_615 VGND VGND VPWR VPWR sky130_fd_sc_hd__fill_1
XFILLER_6_78 VGND VGND VPWR VPWR sky130_fd_sc_hd__decap_3
XFILLER_98_304 VGND VGND VPWR VPWR sky130_fd_sc_hd__decap_3
XFILLER_113_626 VGND VGND VPWR VPWR sky130_fd_sc_hd__decap_3
XFILLER_98_315 VGND VGND VPWR VPWR sky130_fd_sc_hd__decap_3
XFILLER_98_348 VGND VGND VPWR VPWR sky130_fd_sc_hd__fill_1
XFILLER_113_659 VGND VGND VPWR VPWR sky130_fd_sc_hd__decap_3
XFILLER_79_551 VGND VGND VPWR VPWR sky130_fd_sc_hd__decap_3
XFILLER_98_359 VGND VGND VPWR VPWR sky130_fd_sc_hd__decap_3
XTAP_TAPCELL_ROW_72_1161 VGND VPWR sky130_fd_sc_hd__tapvpwrvgnd_1
XFILLER_112_169 VGND VGND VPWR VPWR sky130_fd_sc_hd__fill_1
XFILLER_39_415 VGND VGND VPWR VPWR sky130_fd_sc_hd__decap_3
XFILLER_39_437 VGND VGND VPWR VPWR sky130_fd_sc_hd__fill_2
XFILLER_66_212 VGND VGND VPWR VPWR sky130_fd_sc_hd__decap_3
XFILLER_66_245 VGND VGND VPWR VPWR sky130_fd_sc_hd__decap_3
XFILLER_86_91 VGND VGND VPWR VPWR sky130_fd_sc_hd__decap_3
XFILLER_94_554 VGND VGND VPWR VPWR sky130_fd_sc_hd__decap_3
XFILLER_26_109 VGND VGND VPWR VPWR sky130_fd_sc_hd__decap_3
XFILLER_35_632 VGND VGND VPWR VPWR sky130_fd_sc_hd__decap_3
XFILLER_47_481 VGND VGND VPWR VPWR sky130_fd_sc_hd__fill_2
XFILLER_47_492 VGND VGND VPWR VPWR sky130_fd_sc_hd__fill_1
X_6930_ _7189_/CLK _6930_/D VGND VGND VPWR VPWR _6930_/Q sky130_fd_sc_hd__dfxtp_2
XFILLER_35_665 VGND VGND VPWR VPWR sky130_fd_sc_hd__decap_3
XFILLER_62_451 VGND VGND VPWR VPWR sky130_fd_sc_hd__decap_3
XFILLER_81_248 VGND VGND VPWR VPWR sky130_fd_sc_hd__fill_1
X_6861_ _6906_/CLK _6861_/D VGND VGND VPWR VPWR _6861_/Q sky130_fd_sc_hd__dfxtp_2
XFILLER_22_315 VGND VGND VPWR VPWR sky130_fd_sc_hd__decap_3
XFILLER_34_153 VGND VGND VPWR VPWR sky130_fd_sc_hd__decap_3
XFILLER_34_175 VGND VGND VPWR VPWR sky130_fd_sc_hd__decap_3
XFILLER_35_676 VGND VGND VPWR VPWR sky130_fd_sc_hd__decap_3
X_6792_ _6942_/CLK _6792_/D VGND VGND VPWR VPWR _6792_/Q sky130_fd_sc_hd__dfxtp_2
XFILLER_34_197 VGND VGND VPWR VPWR sky130_fd_sc_hd__decap_3
XFILLER_50_635 VGND VGND VPWR VPWR sky130_fd_sc_hd__decap_3
XFILLER_50_657 VGND VGND VPWR VPWR sky130_fd_sc_hd__decap_3
XTAP_TAPCELL_ROW_83_1290 VGND VPWR sky130_fd_sc_hd__tapvpwrvgnd_1
XTAP_TAPCELL_ROW_20_505 VGND VPWR sky130_fd_sc_hd__tapvpwrvgnd_1
X_5674_ _7343_/Q _5674_/A1 _5721_/S VGND VGND VPWR VPWR _6687_/D sky130_fd_sc_hd__mux2_2
X_4625_ _5099_/A wire667/X _4624_/B _4624_/X VGND VGND VPWR VPWR _4916_/A sky130_fd_sc_hd__a31oi_4
X_7344_ _7344_/CLK _7344_/D _6624_/Y VGND VGND VPWR VPWR _7344_/Q sky130_fd_sc_hd__dfrtp_2
X_4556_ _7302_/Q _4577_/B VGND VGND VPWR VPWR _7302_/D sky130_fd_sc_hd__and2_2
XFILLER_104_604 VGND VGND VPWR VPWR sky130_fd_sc_hd__decap_3
XFILLER_89_304 VGND VGND VPWR VPWR sky130_fd_sc_hd__decap_3
X_3507_ _3458_/Y _3505_/X _3506_/Y VGND VGND VPWR VPWR _3508_/B sky130_fd_sc_hd__o21a_2
XFILLER_103_103 VGND VGND VPWR VPWR sky130_fd_sc_hd__decap_3
XFILLER_104_637 VGND VGND VPWR VPWR sky130_fd_sc_hd__decap_3
XFILLER_104_648 VGND VGND VPWR VPWR sky130_fd_sc_hd__decap_3
XFILLER_89_337 VGND VGND VPWR VPWR sky130_fd_sc_hd__decap_3
X_7275_ _7371_/CLK _7275_/D _6555_/Y VGND VGND VPWR VPWR _7275_/Q sky130_fd_sc_hd__dfrtp_2
XFILLER_103_125 VGND VGND VPWR VPWR sky130_fd_sc_hd__decap_3
XFILLER_103_158 VGND VGND VPWR VPWR sky130_fd_sc_hd__fill_1
X_3438_ _7314_/Q _3996_/S _4346_/B1 _7346_/Q _3556_/A VGND VGND VPWR VPWR _3438_/X
+ sky130_fd_sc_hd__a221o_2
XFILLER_112_681 VGND VGND VPWR VPWR sky130_fd_sc_hd__decap_3
XFILLER_58_713 VGND VGND VPWR VPWR sky130_fd_sc_hd__fill_1
Xhold1200 _7327_/Q VGND VGND VPWR VPWR _4505_/A0 sky130_fd_sc_hd__dlygate4sd3_1
X_3369_ _3371_/A _5668_/A VGND VGND VPWR VPWR _3560_/B sky130_fd_sc_hd__nand2_2
XFILLER_111_191 VGND VGND VPWR VPWR sky130_fd_sc_hd__fill_1
XFILLER_57_212 VGND VGND VPWR VPWR sky130_fd_sc_hd__decap_3
XFILLER_57_234 VGND VGND VPWR VPWR sky130_fd_sc_hd__decap_3
Xhold1211 _7316_/Q VGND VGND VPWR VPWR _4526_/A0 sky130_fd_sc_hd__dlygate4sd3_1
Xhold1222 _7146_/Q VGND VGND VPWR VPWR _5373_/A0 sky130_fd_sc_hd__dlygate4sd3_1
Xhold1233 _7169_/Q VGND VGND VPWR VPWR _5323_/A0 sky130_fd_sc_hd__dlygate4sd3_1
X_5108_ _5108_/A0 _5107_/X _5159_/S VGND VGND VPWR VPWR _7255_/D sky130_fd_sc_hd__mux2_2
Xhold1244 _7303_/Q VGND VGND VPWR VPWR _4554_/A sky130_fd_sc_hd__dlygate4sd3_1
Xhold1255 _7235_/Q VGND VGND VPWR VPWR _5186_/A sky130_fd_sc_hd__dlygate4sd3_1
Xhold1266 _7150_/Q VGND VGND VPWR VPWR _5365_/A0 sky130_fd_sc_hd__dlygate4sd3_1
XTAP_TAPCELL_ROW_28_605 VGND VPWR sky130_fd_sc_hd__tapvpwrvgnd_1
XFILLER_26_610 VGND VGND VPWR VPWR sky130_fd_sc_hd__decap_3
XFILLER_45_429 VGND VGND VPWR VPWR sky130_fd_sc_hd__fill_1
Xhold1277 _7405_/Q VGND VGND VPWR VPWR _3671_/A1 sky130_fd_sc_hd__dlygate4sd3_1
Xhold1288 _7291_/Q VGND VGND VPWR VPWR _4579_/A sky130_fd_sc_hd__dlygate4sd3_1
Xhold1299 _7181_/Q VGND VGND VPWR VPWR _5298_/A0 sky130_fd_sc_hd__dlygate4sd3_1
X_5039_ _4677_/B _3856_/X _5658_/B _5038_/X _5587_/B VGND VGND VPWR VPWR _5039_/X
+ sky130_fd_sc_hd__o32a_2
XFILLER_26_643 VGND VGND VPWR VPWR sky130_fd_sc_hd__fill_1
XFILLER_26_654 VGND VGND VPWR VPWR sky130_fd_sc_hd__decap_3
XTAP_TAPCELL_ROW_56_958 VGND VPWR sky130_fd_sc_hd__tapvpwrvgnd_1
XTAP_TAPCELL_ROW_0_263 VGND VPWR sky130_fd_sc_hd__tapvpwrvgnd_1
XTAP_TAPCELL_ROW_0_252 VGND VPWR sky130_fd_sc_hd__tapvpwrvgnd_1
XTAP_TAPCELL_ROW_0_241 VGND VPWR sky130_fd_sc_hd__tapvpwrvgnd_1
XFILLER_15_21 VGND VGND VPWR VPWR sky130_fd_sc_hd__decap_3
XFILLER_25_153 VGND VGND VPWR VPWR sky130_fd_sc_hd__fill_2
XFILLER_26_687 VGND VGND VPWR VPWR sky130_fd_sc_hd__decap_3
XFILLER_80_270 VGND VGND VPWR VPWR sky130_fd_sc_hd__decap_3
XFILLER_13_337 VGND VGND VPWR VPWR sky130_fd_sc_hd__decap_3
XFILLER_15_65 VGND VGND VPWR VPWR sky130_fd_sc_hd__fill_2
XFILLER_40_134 VGND VGND VPWR VPWR sky130_fd_sc_hd__decap_3
XFILLER_41_635 VGND VGND VPWR VPWR sky130_fd_sc_hd__decap_3
XFILLER_41_668 VGND VGND VPWR VPWR sky130_fd_sc_hd__decap_3
XFILLER_41_679 VGND VGND VPWR VPWR sky130_fd_sc_hd__decap_3
XFILLER_9_308 VGND VGND VPWR VPWR sky130_fd_sc_hd__decap_3
XFILLER_40_178 VGND VGND VPWR VPWR sky130_fd_sc_hd__decap_3
XFILLER_5_503 VGND VGND VPWR VPWR sky130_fd_sc_hd__fill_1
XFILLER_5_514 VGND VGND VPWR VPWR sky130_fd_sc_hd__decap_3
XFILLER_5_536 VGND VGND VPWR VPWR sky130_fd_sc_hd__decap_3
XFILLER_107_442 VGND VGND VPWR VPWR sky130_fd_sc_hd__decap_3
XFILLER_107_464 VGND VGND VPWR VPWR sky130_fd_sc_hd__decap_3
XFILLER_107_497 VGND VGND VPWR VPWR sky130_fd_sc_hd__decap_3
XFILLER_110_607 VGND VGND VPWR VPWR sky130_fd_sc_hd__decap_3
XTAP_TAPCELL_ROW_8_363 VGND VPWR sky130_fd_sc_hd__tapvpwrvgnd_1
XTAP_TAPCELL_ROW_8_352 VGND VPWR sky130_fd_sc_hd__tapvpwrvgnd_1
XFILLER_95_329 VGND VGND VPWR VPWR sky130_fd_sc_hd__fill_1
XFILLER_0_296 VGND VGND VPWR VPWR sky130_fd_sc_hd__fill_2
XFILLER_102_180 VGND VGND VPWR VPWR sky130_fd_sc_hd__decap_3
XFILLER_88_392 VGND VGND VPWR VPWR sky130_fd_sc_hd__decap_3
XFILLER_36_418 VGND VGND VPWR VPWR sky130_fd_sc_hd__fill_2
XFILLER_48_256 VGND VGND VPWR VPWR sky130_fd_sc_hd__decap_3
XFILLER_17_632 VGND VGND VPWR VPWR sky130_fd_sc_hd__decap_3
XFILLER_56_83 VGND VGND VPWR VPWR sky130_fd_sc_hd__fill_1
XFILLER_63_237 VGND VGND VPWR VPWR sky130_fd_sc_hd__decap_3
XFILLER_17_665 VGND VGND VPWR VPWR sky130_fd_sc_hd__decap_3
XFILLER_17_676 VGND VGND VPWR VPWR sky130_fd_sc_hd__decap_3
XFILLER_32_613 VGND VGND VPWR VPWR sky130_fd_sc_hd__decap_3
XFILLER_44_451 VGND VGND VPWR VPWR sky130_fd_sc_hd__decap_3
XTAP_TAPCELL_ROW_106_1588 VGND VPWR sky130_fd_sc_hd__tapvpwrvgnd_1
XTAP_TAPCELL_ROW_106_1577 VGND VPWR sky130_fd_sc_hd__tapvpwrvgnd_1
XFILLER_16_197 VGND VGND VPWR VPWR sky130_fd_sc_hd__decap_3
XFILLER_32_657 VGND VGND VPWR VPWR sky130_fd_sc_hd__decap_3
XFILLER_44_495 VGND VGND VPWR VPWR sky130_fd_sc_hd__fill_1
XFILLER_71_281 VGND VGND VPWR VPWR sky130_fd_sc_hd__decap_3
XFILLER_72_71 VGND VGND VPWR VPWR sky130_fd_sc_hd__decap_3
XFILLER_12_381 VGND VGND VPWR VPWR sky130_fd_sc_hd__decap_3
XFILLER_31_178 VGND VGND VPWR VPWR sky130_fd_sc_hd__decap_3
XFILLER_40_690 VGND VGND VPWR VPWR sky130_fd_sc_hd__decap_3
XFILLER_8_330 VGND VGND VPWR VPWR sky130_fd_sc_hd__decap_3
XFILLER_8_352 VGND VGND VPWR VPWR sky130_fd_sc_hd__decap_3
XFILLER_117_228 VGND VGND VPWR VPWR sky130_fd_sc_hd__fill_1
XFILLER_8_385 VGND VGND VPWR VPWR sky130_fd_sc_hd__fill_1
X_4410_ _4411_/A _4411_/B VGND VGND VPWR VPWR _4788_/B sky130_fd_sc_hd__nor2_2
Xoutput627 _3339_/C1 VGND VGND VPWR VPWR instruction_out[6] sky130_fd_sc_hd__clkdlybuf4s25_1
Xoutput616 _3449_/C VGND VGND VPWR VPWR instruction_out[23] sky130_fd_sc_hd__clkdlybuf4s25_1
Xoutput605 _5647_/Y VGND VGND VPWR VPWR instruction_out[11] sky130_fd_sc_hd__clkdlybuf4s25_1
X_5390_ _5390_/A0 _4932_/X _5390_/S VGND VGND VPWR VPWR _7138_/D sky130_fd_sc_hd__mux2_2
Xoutput649 _7003_/Q VGND VGND VPWR VPWR pc_out[26] sky130_fd_sc_hd__clkdlybuf4s25_1
Xoutput638 _6993_/Q VGND VGND VPWR VPWR pc_out[16] sky130_fd_sc_hd__clkdlybuf4s25_1
X_4341_ _7255_/Q _4601_/S _4348_/B1 _7127_/Q _4340_/X VGND VGND VPWR VPWR _4365_/A
+ sky130_fd_sc_hd__a221o_2
XFILLER_99_635 VGND VGND VPWR VPWR sky130_fd_sc_hd__decap_3
XFILLER_99_613 VGND VGND VPWR VPWR sky130_fd_sc_hd__decap_3
XFILLER_113_434 VGND VGND VPWR VPWR sky130_fd_sc_hd__decap_3
XFILLER_98_156 VGND VGND VPWR VPWR sky130_fd_sc_hd__fill_2
X_7060_ _7344_/CLK _7060_/D _6340_/Y VGND VGND VPWR VPWR _7060_/Q sky130_fd_sc_hd__dfrtp_2
X_4272_ _4394_/A _4272_/B _4271_/X VGND VGND VPWR VPWR _4273_/D sky130_fd_sc_hd__or3b_2
XFILLER_99_679 VGND VGND VPWR VPWR sky130_fd_sc_hd__decap_3
XFILLER_99_668 VGND VGND VPWR VPWR sky130_fd_sc_hd__decap_3
XFILLER_101_629 VGND VGND VPWR VPWR sky130_fd_sc_hd__decap_3
XFILLER_113_478 VGND VGND VPWR VPWR sky130_fd_sc_hd__decap_3
XFILLER_39_201 VGND VGND VPWR VPWR sky130_fd_sc_hd__decap_3
XFILLER_86_329 VGND VGND VPWR VPWR sky130_fd_sc_hd__decap_3
XFILLER_100_128 VGND VGND VPWR VPWR sky130_fd_sc_hd__decap_3
XFILLER_39_223 VGND VGND VPWR VPWR sky130_fd_sc_hd__fill_1
XFILLER_39_267 VGND VGND VPWR VPWR sky130_fd_sc_hd__decap_3
XFILLER_39_278 VGND VGND VPWR VPWR sky130_fd_sc_hd__fill_2
XFILLER_54_215 VGND VGND VPWR VPWR sky130_fd_sc_hd__decap_3
XFILLER_82_513 VGND VGND VPWR VPWR sky130_fd_sc_hd__decap_3
XFILLER_94_384 VGND VGND VPWR VPWR sky130_fd_sc_hd__fill_1
XFILLER_54_259 VGND VGND VPWR VPWR sky130_fd_sc_hd__fill_2
XFILLER_82_579 VGND VGND VPWR VPWR sky130_fd_sc_hd__decap_3
X_6913_ _6944_/CLK _6913_/D VGND VGND VPWR VPWR _6913_/Q sky130_fd_sc_hd__dfxtp_2
XTAP_TAPCELL_ROW_53_917 VGND VPWR sky130_fd_sc_hd__tapvpwrvgnd_1
XFILLER_22_134 VGND VGND VPWR VPWR sky130_fd_sc_hd__decap_3
XFILLER_23_635 VGND VGND VPWR VPWR sky130_fd_sc_hd__decap_3
XFILLER_62_281 VGND VGND VPWR VPWR sky130_fd_sc_hd__decap_3
X_6844_ clkload3/A _6844_/D VGND VGND VPWR VPWR _6844_/Q sky130_fd_sc_hd__dfxtp_2
XFILLER_22_156 VGND VGND VPWR VPWR sky130_fd_sc_hd__decap_3
XFILLER_23_668 VGND VGND VPWR VPWR sky130_fd_sc_hd__decap_3
XFILLER_23_679 VGND VGND VPWR VPWR sky130_fd_sc_hd__decap_3
X_6775_ _6968_/CLK _6775_/D VGND VGND VPWR VPWR _6775_/Q sky130_fd_sc_hd__dfxtp_2
X_3987_ _5682_/A0 _4528_/A _3987_/S VGND VGND VPWR VPWR _7347_/D sky130_fd_sc_hd__mux2_2
XTAP_TAPCELL_ROW_33_674 VGND VPWR sky130_fd_sc_hd__tapvpwrvgnd_1
XFILLER_108_206 VGND VGND VPWR VPWR sky130_fd_sc_hd__decap_3
XFILLER_108_239 VGND VGND VPWR VPWR sky130_fd_sc_hd__decap_3
X_5657_ _5657_/A _5657_/B _5657_/C _5657_/D VGND VGND VPWR VPWR _5664_/C sky130_fd_sc_hd__nor4_2
X_4608_ _4938_/A _4608_/B VGND VGND VPWR VPWR _4608_/Y sky130_fd_sc_hd__nor2_2
XFILLER_104_401 VGND VGND VPWR VPWR sky130_fd_sc_hd__decap_3
XFILLER_116_250 VGND VGND VPWR VPWR sky130_fd_sc_hd__fill_2
XFILLER_117_23 VGND VGND VPWR VPWR sky130_fd_sc_hd__decap_3
XFILLER_2_528 VGND VGND VPWR VPWR sky130_fd_sc_hd__decap_3
XFILLER_2_539 VGND VGND VPWR VPWR sky130_fd_sc_hd__decap_3
X_7327_ _7360_/CLK _7327_/D _6607_/Y VGND VGND VPWR VPWR _7327_/Q sky130_fd_sc_hd__dfrtp_2
XFILLER_104_456 VGND VGND VPWR VPWR sky130_fd_sc_hd__decap_3
XFILLER_117_78 VGND VGND VPWR VPWR sky130_fd_sc_hd__decap_3
XFILLER_89_134 VGND VGND VPWR VPWR sky130_fd_sc_hd__decap_3
X_7258_ _7357_/CLK _7258_/D _6538_/Y VGND VGND VPWR VPWR _7258_/Q sky130_fd_sc_hd__dfrtp_2
XFILLER_104_489 VGND VGND VPWR VPWR sky130_fd_sc_hd__decap_3
XFILLER_77_49 VGND VGND VPWR VPWR sky130_fd_sc_hd__decap_3
XFILLER_89_156 VGND VGND VPWR VPWR sky130_fd_sc_hd__decap_3
XFILLER_89_178 VGND VGND VPWR VPWR sky130_fd_sc_hd__decap_3
XTAP_TAPCELL_ROW_5_322 VGND VPWR sky130_fd_sc_hd__tapvpwrvgnd_1
XFILLER_98_690 VGND VGND VPWR VPWR sky130_fd_sc_hd__decap_3
X_7189_ _7189_/CLK _7189_/D _6469_/Y VGND VGND VPWR VPWR _7189_/Q sky130_fd_sc_hd__dfrtp_2
XFILLER_100_651 VGND VGND VPWR VPWR sky130_fd_sc_hd__decap_3
XFILLER_18_407 VGND VGND VPWR VPWR sky130_fd_sc_hd__decap_3
Xhold1030 _7036_/Q VGND VGND VPWR VPWR _5585_/A1 sky130_fd_sc_hd__dlygate4sd3_1
Xhold1041 _7041_/Q VGND VGND VPWR VPWR _5576_/A1 sky130_fd_sc_hd__dlygate4sd3_1
XFILLER_100_684 VGND VGND VPWR VPWR sky130_fd_sc_hd__decap_3
XFILLER_45_215 VGND VGND VPWR VPWR sky130_fd_sc_hd__decap_3
XFILLER_85_373 VGND VGND VPWR VPWR sky130_fd_sc_hd__decap_3
Xhold1052 _7320_/Q VGND VGND VPWR VPWR _4519_/A1 sky130_fd_sc_hd__dlygate4sd3_1
Xhold1063 _7026_/Q VGND VGND VPWR VPWR _5602_/A sky130_fd_sc_hd__dlygate4sd3_1
Xhold1074 _7045_/Q VGND VGND VPWR VPWR _5572_/A1 sky130_fd_sc_hd__dlygate4sd3_1
Xhold1085 _7038_/Q VGND VGND VPWR VPWR _5581_/A0 sky130_fd_sc_hd__dlygate4sd3_1
XFILLER_26_440 VGND VGND VPWR VPWR sky130_fd_sc_hd__fill_2
Xhold1096 _7194_/Q VGND VGND VPWR VPWR _5272_/A0 sky130_fd_sc_hd__dlygate4sd3_1
XFILLER_14_613 VGND VGND VPWR VPWR sky130_fd_sc_hd__decap_3
Xclkbuf_3_6__f_clk clkbuf_0_clk/X VGND VGND VPWR VPWR clkbuf_3_6__f_clk/X sky130_fd_sc_hd__clkbuf_16
XFILLER_14_657 VGND VGND VPWR VPWR sky130_fd_sc_hd__decap_3
XFILLER_26_495 VGND VGND VPWR VPWR sky130_fd_sc_hd__decap_3
XFILLER_26_97 VGND VGND VPWR VPWR sky130_fd_sc_hd__decap_3
XFILLER_41_410 VGND VGND VPWR VPWR sky130_fd_sc_hd__fill_2
XFILLER_53_281 VGND VGND VPWR VPWR sky130_fd_sc_hd__decap_3
XFILLER_9_116 VGND VGND VPWR VPWR sky130_fd_sc_hd__decap_3
XFILLER_13_178 VGND VGND VPWR VPWR sky130_fd_sc_hd__decap_3
XFILLER_9_127 VGND VGND VPWR VPWR sky130_fd_sc_hd__decap_3
XFILLER_22_690 VGND VGND VPWR VPWR sky130_fd_sc_hd__decap_3
XFILLER_42_74 VGND VGND VPWR VPWR sky130_fd_sc_hd__fill_1
XFILLER_42_85 VGND VGND VPWR VPWR sky130_fd_sc_hd__fill_2
XFILLER_5_311 VGND VGND VPWR VPWR sky130_fd_sc_hd__decap_3
XFILLER_114_209 VGND VGND VPWR VPWR sky130_fd_sc_hd__fill_2
XFILLER_5_355 VGND VGND VPWR VPWR sky130_fd_sc_hd__decap_3
XFILLER_47_9 VGND VGND VPWR VPWR sky130_fd_sc_hd__fill_1
XFILLER_1_550 VGND VGND VPWR VPWR sky130_fd_sc_hd__decap_3
XFILLER_1_561 VGND VGND VPWR VPWR sky130_fd_sc_hd__decap_3
XFILLER_96_616 VGND VGND VPWR VPWR sky130_fd_sc_hd__decap_3
XFILLER_110_437 VGND VGND VPWR VPWR sky130_fd_sc_hd__decap_3
XFILLER_1_594 VGND VGND VPWR VPWR sky130_fd_sc_hd__decap_3
XFILLER_95_137 VGND VGND VPWR VPWR sky130_fd_sc_hd__decap_3
XFILLER_49_565 VGND VGND VPWR VPWR sky130_fd_sc_hd__decap_3
XFILLER_36_215 VGND VGND VPWR VPWR sky130_fd_sc_hd__decap_3
XFILLER_91_321 VGND VGND VPWR VPWR sky130_fd_sc_hd__decap_3
XTAP_TAPCELL_ROW_108_1606 VGND VPWR sky130_fd_sc_hd__tapvpwrvgnd_1
XFILLER_36_237 VGND VGND VPWR VPWR sky130_fd_sc_hd__decap_3
XFILLER_36_259 VGND VGND VPWR VPWR sky130_fd_sc_hd__decap_3
XFILLER_91_343 VGND VGND VPWR VPWR sky130_fd_sc_hd__fill_2
XFILLER_91_354 VGND VGND VPWR VPWR sky130_fd_sc_hd__decap_3
XFILLER_91_387 VGND VGND VPWR VPWR sky130_fd_sc_hd__decap_3
XFILLER_32_421 VGND VGND VPWR VPWR sky130_fd_sc_hd__decap_3
XFILLER_44_270 VGND VGND VPWR VPWR sky130_fd_sc_hd__decap_3
XFILLER_83_81 VGND VGND VPWR VPWR sky130_fd_sc_hd__decap_3
X_4890_ _5101_/A _4890_/B VGND VGND VPWR VPWR _4890_/Y sky130_fd_sc_hd__nor2_2
X_3910_ _6916_/Q _3921_/A2 _3910_/B1 _6780_/Q VGND VGND VPWR VPWR _3910_/X sky130_fd_sc_hd__a22o_2
XTAP_TAPCELL_ROW_67_1093 VGND VPWR sky130_fd_sc_hd__tapvpwrvgnd_1
XFILLER_20_616 VGND VGND VPWR VPWR sky130_fd_sc_hd__decap_3
XFILLER_32_454 VGND VGND VPWR VPWR sky130_fd_sc_hd__decap_3
X_3841_ _6845_/Q _3851_/A2 _3887_/A2 _6830_/Q _3840_/X VGND VGND VPWR VPWR _3841_/X
+ sky130_fd_sc_hd__a221o_2
XFILLER_80_3 VGND VGND VPWR VPWR sky130_fd_sc_hd__decap_3
X_6560_ _6624_/A VGND VGND VPWR VPWR _6560_/Y sky130_fd_sc_hd__inv_2
X_3772_ _6854_/Q _3913_/B1 _3912_/B1 _6902_/Q _3771_/X VGND VGND VPWR VPWR _3772_/X
+ sky130_fd_sc_hd__a221o_2
XTAP_TAPCELL_ROW_80_1260 VGND VPWR sky130_fd_sc_hd__tapvpwrvgnd_1
XTAP_TAPCELL_ROW_30_633 VGND VPWR sky130_fd_sc_hd__tapvpwrvgnd_1
XFILLER_9_650 VGND VGND VPWR VPWR sky130_fd_sc_hd__decap_3
X_6491_ _6647_/A VGND VGND VPWR VPWR _6491_/Y sky130_fd_sc_hd__inv_2
XTAP_TAPCELL_ROW_119_1757 VGND VPWR sky130_fd_sc_hd__tapvpwrvgnd_1
XTAP_TAPCELL_ROW_119_1746 VGND VPWR sky130_fd_sc_hd__tapvpwrvgnd_1
XFILLER_9_694 VGND VGND VPWR VPWR sky130_fd_sc_hd__decap_3
XFILLER_114_710 VGND VGND VPWR VPWR sky130_fd_sc_hd__decap_3
X_5373_ _5373_/A0 _4792_/X _5379_/S VGND VGND VPWR VPWR _7146_/D sky130_fd_sc_hd__mux2_2
XFILLER_99_421 VGND VGND VPWR VPWR sky130_fd_sc_hd__decap_3
X_7112_ _7342_/CLK _7112_/D _6392_/Y VGND VGND VPWR VPWR _7112_/Q sky130_fd_sc_hd__dfrtp_2
X_4324_ _7039_/Q _4244_/B _4354_/B1 _7386_/Q VGND VGND VPWR VPWR _4324_/X sky130_fd_sc_hd__a22o_2
XFILLER_101_415 VGND VGND VPWR VPWR sky130_fd_sc_hd__decap_3
X_7043_ _7358_/CLK _7043_/D _6323_/Y VGND VGND VPWR VPWR _7043_/Q sky130_fd_sc_hd__dfrtp_2
XFILLER_113_275 VGND VGND VPWR VPWR sky130_fd_sc_hd__decap_3
XFILLER_59_329 VGND VGND VPWR VPWR sky130_fd_sc_hd__fill_1
XFILLER_86_126 VGND VGND VPWR VPWR sky130_fd_sc_hd__decap_3
XFILLER_87_649 VGND VGND VPWR VPWR sky130_fd_sc_hd__decap_3
X_4255_ _4251_/X _4254_/X _4327_/A VGND VGND VPWR VPWR _4256_/C sky130_fd_sc_hd__o21ai_2
XFILLER_99_498 VGND VGND VPWR VPWR sky130_fd_sc_hd__decap_3
XFILLER_67_340 VGND VGND VPWR VPWR sky130_fd_sc_hd__decap_3
XFILLER_86_159 VGND VGND VPWR VPWR sky130_fd_sc_hd__decap_3
X_4186_ _4186_/A _4636_/B VGND VGND VPWR VPWR _4200_/A sky130_fd_sc_hd__xnor2_2
XFILLER_27_204 VGND VGND VPWR VPWR sky130_fd_sc_hd__decap_3
XFILLER_55_502 VGND VGND VPWR VPWR sky130_fd_sc_hd__fill_2
XFILLER_94_170 VGND VGND VPWR VPWR sky130_fd_sc_hd__decap_3
XFILLER_95_671 VGND VGND VPWR VPWR sky130_fd_sc_hd__fill_1
XFILLER_95_682 VGND VGND VPWR VPWR sky130_fd_sc_hd__decap_3
XFILLER_27_237 VGND VGND VPWR VPWR sky130_fd_sc_hd__decap_3
XTAP_TAPCELL_ROW_38_733 VGND VPWR sky130_fd_sc_hd__tapvpwrvgnd_1
XFILLER_103_69 VGND VGND VPWR VPWR sky130_fd_sc_hd__decap_3
XFILLER_42_218 VGND VGND VPWR VPWR sky130_fd_sc_hd__decap_3
XFILLER_82_365 VGND VGND VPWR VPWR sky130_fd_sc_hd__decap_3
XPHY_EDGE_ROW_118_Right_118 VGND VGND VPWR VPWR sky130_fd_sc_hd__decap_3
XFILLER_35_281 VGND VGND VPWR VPWR sky130_fd_sc_hd__decap_3
XFILLER_70_549 VGND VGND VPWR VPWR sky130_fd_sc_hd__fill_1
X_6827_ clkload5/A _6827_/D VGND VGND VPWR VPWR _6827_/Q sky130_fd_sc_hd__dfxtp_2
XFILLER_11_638 VGND VGND VPWR VPWR sky130_fd_sc_hd__decap_3
XFILLER_23_498 VGND VGND VPWR VPWR sky130_fd_sc_hd__decap_3
XFILLER_50_262 VGND VGND VPWR VPWR sky130_fd_sc_hd__decap_3
XFILLER_12_11 VGND VGND VPWR VPWR sky130_fd_sc_hd__fill_1
XFILLER_7_609 VGND VGND VPWR VPWR sky130_fd_sc_hd__decap_3
X_6758_ _6968_/CLK _6758_/D VGND VGND VPWR VPWR _6758_/Q sky130_fd_sc_hd__dfxtp_2
X_6689_ _6923_/CLK _6689_/D VGND VGND VPWR VPWR _6689_/Q sky130_fd_sc_hd__dfxtp_2
XFILLER_109_559 VGND VGND VPWR VPWR sky130_fd_sc_hd__fill_1
XTAP_TAPCELL_ROW_94_1429 VGND VPWR sky130_fd_sc_hd__tapvpwrvgnd_1
XFILLER_88_26 VGND VGND VPWR VPWR sky130_fd_sc_hd__fill_2
XFILLER_2_347 VGND VGND VPWR VPWR sky130_fd_sc_hd__decap_3
XFILLER_104_242 VGND VGND VPWR VPWR sky130_fd_sc_hd__decap_3
XFILLER_104_253 VGND VGND VPWR VPWR sky130_fd_sc_hd__decap_3
XFILLER_78_638 VGND VGND VPWR VPWR sky130_fd_sc_hd__decap_3
XFILLER_86_660 VGND VGND VPWR VPWR sky130_fd_sc_hd__decap_3
XFILLER_86_693 VGND VGND VPWR VPWR sky130_fd_sc_hd__decap_3
XFILLER_92_118 VGND VGND VPWR VPWR sky130_fd_sc_hd__decap_3
XFILLER_85_192 VGND VGND VPWR VPWR sky130_fd_sc_hd__decap_3
XFILLER_33_207 VGND VGND VPWR VPWR sky130_fd_sc_hd__decap_3
XFILLER_37_96 VGND VGND VPWR VPWR sky130_fd_sc_hd__decap_3
XFILLER_61_505 VGND VGND VPWR VPWR sky130_fd_sc_hd__decap_3
XFILLER_14_421 VGND VGND VPWR VPWR sky130_fd_sc_hd__decap_3
XFILLER_26_281 VGND VGND VPWR VPWR sky130_fd_sc_hd__decap_3
XFILLER_14_454 VGND VGND VPWR VPWR sky130_fd_sc_hd__decap_3
XFILLER_53_40 VGND VGND VPWR VPWR sky130_fd_sc_hd__decap_3
XTAP_TAPCELL_ROW_103_1547 VGND VPWR sky130_fd_sc_hd__tapvpwrvgnd_1
XFILLER_41_284 VGND VGND VPWR VPWR sky130_fd_sc_hd__decap_3
XFILLER_53_84 VGND VGND VPWR VPWR sky130_fd_sc_hd__fill_2
XFILLER_10_660 VGND VGND VPWR VPWR sky130_fd_sc_hd__decap_3
XFILLER_10_693 VGND VGND VPWR VPWR sky130_fd_sc_hd__decap_3
XFILLER_6_631 VGND VGND VPWR VPWR sky130_fd_sc_hd__decap_3
XFILLER_6_675 VGND VGND VPWR VPWR sky130_fd_sc_hd__decap_3
XFILLER_108_581 VGND VGND VPWR VPWR sky130_fd_sc_hd__decap_3
XFILLER_108_592 VGND VGND VPWR VPWR sky130_fd_sc_hd__decap_3
XTAP_TAPCELL_ROW_114_1687 VGND VPWR sky130_fd_sc_hd__tapvpwrvgnd_1
XFILLER_69_638 VGND VGND VPWR VPWR sky130_fd_sc_hd__decap_3
XFILLER_96_435 VGND VGND VPWR VPWR sky130_fd_sc_hd__decap_3
XFILLER_110_256 VGND VGND VPWR VPWR sky130_fd_sc_hd__decap_3
XFILLER_1_391 VGND VGND VPWR VPWR sky130_fd_sc_hd__fill_1
XFILLER_68_159 VGND VGND VPWR VPWR sky130_fd_sc_hd__decap_3
XFILLER_84_619 VGND VGND VPWR VPWR sky130_fd_sc_hd__decap_3
XFILLER_96_457 VGND VGND VPWR VPWR sky130_fd_sc_hd__decap_3
X_4040_ _4608_/B _4040_/B VGND VGND VPWR VPWR _4040_/Y sky130_fd_sc_hd__nor2_2
XFILLER_49_373 VGND VGND VPWR VPWR sky130_fd_sc_hd__decap_3
XFILLER_49_384 VGND VGND VPWR VPWR sky130_fd_sc_hd__decap_3
XFILLER_77_671 VGND VGND VPWR VPWR sky130_fd_sc_hd__fill_1
XFILLER_77_682 VGND VGND VPWR VPWR sky130_fd_sc_hd__decap_3
XFILLER_76_192 VGND VGND VPWR VPWR sky130_fd_sc_hd__decap_3
XTAP_TAPCELL_ROW_69_1122 VGND VPWR sky130_fd_sc_hd__tapvpwrvgnd_1
XFILLER_24_218 VGND VGND VPWR VPWR sky130_fd_sc_hd__decap_3
XFILLER_52_527 VGND VGND VPWR VPWR sky130_fd_sc_hd__decap_3
XFILLER_64_365 VGND VGND VPWR VPWR sky130_fd_sc_hd__decap_3
XFILLER_91_151 VGND VGND VPWR VPWR sky130_fd_sc_hd__decap_3
XFILLER_92_663 VGND VGND VPWR VPWR sky130_fd_sc_hd__decap_3
XFILLER_94_91 VGND VGND VPWR VPWR sky130_fd_sc_hd__decap_3
XFILLER_17_281 VGND VGND VPWR VPWR sky130_fd_sc_hd__decap_3
XFILLER_64_387 VGND VGND VPWR VPWR sky130_fd_sc_hd__fill_1
XFILLER_91_184 VGND VGND VPWR VPWR sky130_fd_sc_hd__decap_3
XFILLER_92_696 VGND VGND VPWR VPWR sky130_fd_sc_hd__decap_3
X_4942_ _6995_/Q _4960_/B _4677_/B _5667_/A VGND VGND VPWR VPWR _4943_/B sky130_fd_sc_hd__o211ai_2
XFILLER_32_262 VGND VGND VPWR VPWR sky130_fd_sc_hd__decap_3
X_6612_ _6612_/A VGND VGND VPWR VPWR _6612_/Y sky130_fd_sc_hd__inv_2
X_4873_ _4764_/B _4111_/B _4845_/A _5101_/A VGND VGND VPWR VPWR _4873_/X sky130_fd_sc_hd__o22a_2
X_3824_ _6965_/Q _3912_/A2 _3913_/A2 _6953_/Q _3823_/X VGND VGND VPWR VPWR _3824_/X
+ sky130_fd_sc_hd__a221o_2
XTAP_TAPCELL_ROW_43_791 VGND VPWR sky130_fd_sc_hd__tapvpwrvgnd_1
X_6543_ _6642_/A VGND VGND VPWR VPWR _6543_/Y sky130_fd_sc_hd__inv_2
X_3755_ _6934_/Q _3926_/A2 _3767_/B1 _6886_/Q VGND VGND VPWR VPWR _3755_/X sky130_fd_sc_hd__a22o_2
X_6474_ _6637_/A VGND VGND VPWR VPWR _6474_/Y sky130_fd_sc_hd__inv_2
XFILLER_106_518 VGND VGND VPWR VPWR sky130_fd_sc_hd__decap_3
X_5425_ _5425_/A0 _3993_/X _5427_/S VGND VGND VPWR VPWR _7121_/D sky130_fd_sc_hd__mux2_2
XPHY_EDGE_ROW_12_Right_12 VGND VGND VPWR VPWR sky130_fd_sc_hd__decap_3
XFILLER_102_713 VGND VGND VPWR VPWR sky130_fd_sc_hd__fill_1
XFILLER_114_573 VGND VGND VPWR VPWR sky130_fd_sc_hd__decap_3
XFILLER_58_29 VGND VGND VPWR VPWR sky130_fd_sc_hd__decap_3
X_5356_ _5356_/A0 _3993_/X _5360_/S VGND VGND VPWR VPWR _7153_/D sky130_fd_sc_hd__mux2_2
XFILLER_99_251 VGND VGND VPWR VPWR sky130_fd_sc_hd__decap_3
XFILLER_101_212 VGND VGND VPWR VPWR sky130_fd_sc_hd__decap_3
XFILLER_114_595 VGND VGND VPWR VPWR sky130_fd_sc_hd__decap_3
XFILLER_59_137 VGND VGND VPWR VPWR sky130_fd_sc_hd__decap_3
X_4307_ _7224_/Q _4307_/A2 _4300_/B _7037_/Q VGND VGND VPWR VPWR _4307_/X sky130_fd_sc_hd__a22o_2
XFILLER_99_284 VGND VGND VPWR VPWR sky130_fd_sc_hd__decap_3
XFILLER_99_273 VGND VGND VPWR VPWR sky130_fd_sc_hd__decap_3
XFILLER_87_479 VGND VGND VPWR VPWR sky130_fd_sc_hd__fill_2
X_7026_ _7371_/CLK _7026_/D _6306_/Y VGND VGND VPWR VPWR _7026_/Q sky130_fd_sc_hd__dfrtp_2
X_4238_ _7067_/Q _4305_/B _4460_/A _4237_/X VGND VGND VPWR VPWR _4629_/B sky130_fd_sc_hd__o211ai_2
XFILLER_114_35 VGND VGND VPWR VPWR sky130_fd_sc_hd__decap_3
XFILLER_68_660 VGND VGND VPWR VPWR sky130_fd_sc_hd__decap_3
XFILLER_68_693 VGND VGND VPWR VPWR sky130_fd_sc_hd__decap_3
XFILLER_74_118 VGND VGND VPWR VPWR sky130_fd_sc_hd__decap_3
XFILLER_114_68 VGND VGND VPWR VPWR sky130_fd_sc_hd__decap_3
XFILLER_55_343 VGND VGND VPWR VPWR sky130_fd_sc_hd__decap_3
XFILLER_67_192 VGND VGND VPWR VPWR sky130_fd_sc_hd__decap_3
XFILLER_83_641 VGND VGND VPWR VPWR sky130_fd_sc_hd__decap_3
X_4169_ _4165_/X _4168_/X _4425_/A VGND VGND VPWR VPWR _4202_/A sky130_fd_sc_hd__o21a_2
XFILLER_43_505 VGND VGND VPWR VPWR sky130_fd_sc_hd__decap_3
XFILLER_83_685 VGND VGND VPWR VPWR sky130_fd_sc_hd__decap_3
XPHY_EDGE_ROW_21_Right_21 VGND VGND VPWR VPWR sky130_fd_sc_hd__decap_3
XFILLER_55_387 VGND VGND VPWR VPWR sky130_fd_sc_hd__decap_3
XFILLER_23_251 VGND VGND VPWR VPWR sky130_fd_sc_hd__decap_3
XTAP_TAPCELL_ROW_13_419 VGND VPWR sky130_fd_sc_hd__tapvpwrvgnd_1
XFILLER_11_457 VGND VGND VPWR VPWR sky130_fd_sc_hd__fill_1
XFILLER_23_54 VGND VGND VPWR VPWR sky130_fd_sc_hd__fill_2
XFILLER_109_312 VGND VGND VPWR VPWR sky130_fd_sc_hd__decap_3
XFILLER_11_479 VGND VGND VPWR VPWR sky130_fd_sc_hd__decap_3
XFILLER_109_334 VGND VGND VPWR VPWR sky130_fd_sc_hd__fill_2
XFILLER_23_98 VGND VGND VPWR VPWR sky130_fd_sc_hd__decap_3
XPHY_EDGE_ROW_30_Right_30 VGND VGND VPWR VPWR sky130_fd_sc_hd__decap_3
XFILLER_99_36 VGND VGND VPWR VPWR sky130_fd_sc_hd__fill_2
XFILLER_109_389 VGND VGND VPWR VPWR sky130_fd_sc_hd__decap_3
XFILLER_3_623 VGND VGND VPWR VPWR sky130_fd_sc_hd__decap_3
XFILLER_105_540 VGND VGND VPWR VPWR sky130_fd_sc_hd__decap_3
XFILLER_3_656 VGND VGND VPWR VPWR sky130_fd_sc_hd__decap_3
XFILLER_78_402 VGND VGND VPWR VPWR sky130_fd_sc_hd__decap_3
XFILLER_78_424 VGND VGND VPWR VPWR sky130_fd_sc_hd__decap_3
XFILLER_59_671 VGND VGND VPWR VPWR sky130_fd_sc_hd__fill_1
XFILLER_59_682 VGND VGND VPWR VPWR sky130_fd_sc_hd__decap_3
XFILLER_58_181 VGND VGND VPWR VPWR sky130_fd_sc_hd__decap_3
XFILLER_74_630 VGND VGND VPWR VPWR sky130_fd_sc_hd__decap_3
XFILLER_93_449 VGND VGND VPWR VPWR sky130_fd_sc_hd__decap_3
XFILLER_34_505 VGND VGND VPWR VPWR sky130_fd_sc_hd__decap_3
XFILLER_46_376 VGND VGND VPWR VPWR sky130_fd_sc_hd__decap_3
XFILLER_74_663 VGND VGND VPWR VPWR sky130_fd_sc_hd__decap_3
XFILLER_46_398 VGND VGND VPWR VPWR sky130_fd_sc_hd__decap_3
XFILLER_74_696 VGND VGND VPWR VPWR sky130_fd_sc_hd__decap_3
XFILLER_61_346 VGND VGND VPWR VPWR sky130_fd_sc_hd__decap_3
XFILLER_61_357 VGND VGND VPWR VPWR sky130_fd_sc_hd__fill_2
XFILLER_61_368 VGND VGND VPWR VPWR sky130_fd_sc_hd__decap_3
XPHY_EDGE_ROW_14_Left_134 VGND VGND VPWR VPWR sky130_fd_sc_hd__decap_3
XFILLER_14_262 VGND VGND VPWR VPWR sky130_fd_sc_hd__decap_3
XTAP_TAPCELL_ROW_64_1063 VGND VPWR sky130_fd_sc_hd__tapvpwrvgnd_1
XTAP_TAPCELL_ROW_64_1052 VGND VPWR sky130_fd_sc_hd__tapvpwrvgnd_1
XFILLER_9_45 VGND VGND VPWR VPWR sky130_fd_sc_hd__decap_3
XFILLER_14_295 VGND VGND VPWR VPWR sky130_fd_sc_hd__decap_3
XFILLER_9_78 VGND VGND VPWR VPWR sky130_fd_sc_hd__decap_3
XFILLER_80_82 VGND VGND VPWR VPWR sky130_fd_sc_hd__fill_2
XTAP_TAPCELL_ROW_40_761 VGND VPWR sky130_fd_sc_hd__tapvpwrvgnd_1
X_3540_ _3502_/A _3502_/B _3485_/C VGND VGND VPWR VPWR _3540_/X sky130_fd_sc_hd__o21a_2
XTAP_TAPCELL_ROW_116_1705 VGND VPWR sky130_fd_sc_hd__tapvpwrvgnd_1
XFILLER_115_315 VGND VGND VPWR VPWR sky130_fd_sc_hd__decap_3
XFILLER_6_450 VGND VGND VPWR VPWR sky130_fd_sc_hd__decap_3
Xhold907 _6763_/Q VGND VGND VPWR VPWR _6763_/D sky130_fd_sc_hd__dlygate4sd3_1
Xhold918 _6760_/Q VGND VGND VPWR VPWR _6760_/D sky130_fd_sc_hd__dlygate4sd3_1
XFILLER_115_337 VGND VGND VPWR VPWR sky130_fd_sc_hd__decap_3
Xhold929 _6819_/Q VGND VGND VPWR VPWR _6819_/D sky130_fd_sc_hd__dlygate4sd3_1
X_3471_ _3545_/A _3545_/B VGND VGND VPWR VPWR _3505_/A sky130_fd_sc_hd__and2b_2
XPHY_EDGE_ROW_23_Left_143 VGND VGND VPWR VPWR sky130_fd_sc_hd__decap_3
XFILLER_89_91 VGND VGND VPWR VPWR sky130_fd_sc_hd__decap_3
XFILLER_97_700 VGND VGND VPWR VPWR sky130_fd_sc_hd__decap_3
XTAP_TAPCELL_ROW_75_1192 VGND VPWR sky130_fd_sc_hd__tapvpwrvgnd_1
XFILLER_57_608 VGND VGND VPWR VPWR sky130_fd_sc_hd__decap_3
XFILLER_69_446 VGND VGND VPWR VPWR sky130_fd_sc_hd__fill_2
X_5072_ _5072_/A _5072_/B _5072_/C VGND VGND VPWR VPWR _5075_/B sky130_fd_sc_hd__and3_2
XFILLER_111_576 VGND VGND VPWR VPWR sky130_fd_sc_hd__decap_3
XFILLER_56_118 VGND VGND VPWR VPWR sky130_fd_sc_hd__decap_3
XFILLER_84_405 VGND VGND VPWR VPWR sky130_fd_sc_hd__decap_3
XFILLER_84_427 VGND VGND VPWR VPWR sky130_fd_sc_hd__decap_3
XFILLER_84_438 VGND VGND VPWR VPWR sky130_fd_sc_hd__decap_3
XFILLER_37_310 VGND VGND VPWR VPWR sky130_fd_sc_hd__decap_3
XFILLER_49_192 VGND VGND VPWR VPWR sky130_fd_sc_hd__decap_3
XFILLER_65_641 VGND VGND VPWR VPWR sky130_fd_sc_hd__decap_3
XFILLER_25_505 VGND VGND VPWR VPWR sky130_fd_sc_hd__decap_3
XFILLER_37_343 VGND VGND VPWR VPWR sky130_fd_sc_hd__decap_3
XFILLER_65_685 VGND VGND VPWR VPWR sky130_fd_sc_hd__decap_3
XTAP_TAPCELL_ROW_48_861 VGND VPWR sky130_fd_sc_hd__tapvpwrvgnd_1
XFILLER_25_549 VGND VGND VPWR VPWR sky130_fd_sc_hd__decap_3
XFILLER_64_162 VGND VGND VPWR VPWR sky130_fd_sc_hd__decap_3
XFILLER_64_195 VGND VGND VPWR VPWR sky130_fd_sc_hd__fill_1
XFILLER_80_633 VGND VGND VPWR VPWR sky130_fd_sc_hd__decap_3
XPHY_EDGE_ROW_32_Left_152 VGND VGND VPWR VPWR sky130_fd_sc_hd__decap_3
XFILLER_52_368 VGND VGND VPWR VPWR sky130_fd_sc_hd__decap_3
XFILLER_80_666 VGND VGND VPWR VPWR sky130_fd_sc_hd__decap_3
XFILLER_21_700 VGND VGND VPWR VPWR sky130_fd_sc_hd__decap_3
XFILLER_33_582 VGND VGND VPWR VPWR sky130_fd_sc_hd__decap_3
XFILLER_80_699 VGND VGND VPWR VPWR sky130_fd_sc_hd__fill_1
X_4925_ _4764_/B _4158_/A _4920_/A _5101_/A _4924_/X VGND VGND VPWR VPWR _4925_/X
+ sky130_fd_sc_hd__o221a_2
XFILLER_100_59 VGND VGND VPWR VPWR sky130_fd_sc_hd__fill_1
X_3807_ _6703_/Q _3889_/B1 _3887_/B1 _6881_/Q VGND VGND VPWR VPWR _3807_/X sky130_fd_sc_hd__a22o_2
XFILLER_118_131 VGND VGND VPWR VPWR sky130_fd_sc_hd__decap_3
XFILLER_119_632 VGND VGND VPWR VPWR sky130_fd_sc_hd__fill_2
XFILLER_119_654 VGND VGND VPWR VPWR sky130_fd_sc_hd__decap_3
X_6526_ _6653_/A VGND VGND VPWR VPWR _6526_/Y sky130_fd_sc_hd__inv_2
X_4787_ _4787_/A _4787_/B VGND VGND VPWR VPWR _4787_/Y sky130_fd_sc_hd__xnor2_2
XFILLER_106_304 VGND VGND VPWR VPWR sky130_fd_sc_hd__decap_3
XFILLER_106_315 VGND VGND VPWR VPWR sky130_fd_sc_hd__decap_3
XFILLER_109_24 VGND VGND VPWR VPWR sky130_fd_sc_hd__decap_3
XFILLER_119_676 VGND VGND VPWR VPWR sky130_fd_sc_hd__decap_3
X_3738_ _6740_/Q _3886_/B1 _3889_/B1 _6734_/Q _3737_/X VGND VGND VPWR VPWR _3738_/X
+ sky130_fd_sc_hd__a221o_2
XPHY_EDGE_ROW_41_Left_161 VGND VGND VPWR VPWR sky130_fd_sc_hd__decap_3
XFILLER_109_57 VGND VGND VPWR VPWR sky130_fd_sc_hd__decap_3
XFILLER_118_186 VGND VGND VPWR VPWR sky130_fd_sc_hd__decap_3
XFILLER_118_197 VGND VGND VPWR VPWR sky130_fd_sc_hd__decap_3
XFILLER_69_28 VGND VGND VPWR VPWR sky130_fd_sc_hd__decap_3
X_6457_ _6554_/A VGND VGND VPWR VPWR _6457_/Y sky130_fd_sc_hd__inv_2
X_3669_ _6807_/Q _3759_/A2 _3760_/B1 _6717_/Q _3668_/X VGND VGND VPWR VPWR _3669_/X
+ sky130_fd_sc_hd__a221o_2
X_6388_ _6612_/A VGND VGND VPWR VPWR _6388_/Y sky130_fd_sc_hd__inv_2
XFILLER_0_626 VGND VGND VPWR VPWR sky130_fd_sc_hd__decap_3
XFILLER_102_510 VGND VGND VPWR VPWR sky130_fd_sc_hd__decap_3
XFILLER_0_648 VGND VGND VPWR VPWR sky130_fd_sc_hd__decap_3
XFILLER_48_608 VGND VGND VPWR VPWR sky130_fd_sc_hd__decap_3
XFILLER_87_243 VGND VGND VPWR VPWR sky130_fd_sc_hd__decap_3
XFILLER_102_576 VGND VGND VPWR VPWR sky130_fd_sc_hd__decap_3
XFILLER_87_287 VGND VGND VPWR VPWR sky130_fd_sc_hd__decap_3
XFILLER_75_449 VGND VGND VPWR VPWR sky130_fd_sc_hd__decap_3
X_7009_ _7086_/CLK _7009_/Q _6289_/Y VGND VGND VPWR VPWR _7009_/Q sky130_fd_sc_hd__dfrtp_2
XPHY_EDGE_ROW_50_Left_170 VGND VGND VPWR VPWR sky130_fd_sc_hd__decap_3
XFILLER_28_365 VGND VGND VPWR VPWR sky130_fd_sc_hd__decap_3
XFILLER_56_663 VGND VGND VPWR VPWR sky130_fd_sc_hd__decap_3
XFILLER_90_408 VGND VGND VPWR VPWR sky130_fd_sc_hd__decap_3
XFILLER_16_527 VGND VGND VPWR VPWR sky130_fd_sc_hd__decap_3
XFILLER_28_398 VGND VGND VPWR VPWR sky130_fd_sc_hd__decap_3
XFILLER_43_302 VGND VGND VPWR VPWR sky130_fd_sc_hd__decap_3
XFILLER_55_162 VGND VGND VPWR VPWR sky130_fd_sc_hd__decap_3
XFILLER_56_696 VGND VGND VPWR VPWR sky130_fd_sc_hd__decap_3
XFILLER_71_644 VGND VGND VPWR VPWR sky130_fd_sc_hd__decap_3
XFILLER_83_482 VGND VGND VPWR VPWR sky130_fd_sc_hd__decap_3
XFILLER_34_64 VGND VGND VPWR VPWR sky130_fd_sc_hd__decap_3
XFILLER_43_379 VGND VGND VPWR VPWR sky130_fd_sc_hd__decap_3
XFILLER_71_688 VGND VGND VPWR VPWR sky130_fd_sc_hd__decap_3
XTAP_TAPCELL_ROW_26_588 VGND VPWR sky130_fd_sc_hd__tapvpwrvgnd_1
XTAP_TAPCELL_ROW_26_577 VGND VPWR sky130_fd_sc_hd__tapvpwrvgnd_1
XTAP_TAPCELL_ROW_100_1506 VGND VPWR sky130_fd_sc_hd__tapvpwrvgnd_1
XFILLER_11_221 VGND VGND VPWR VPWR sky130_fd_sc_hd__decap_3
XFILLER_8_704 VGND VGND VPWR VPWR sky130_fd_sc_hd__decap_3
XFILLER_7_203 VGND VGND VPWR VPWR sky130_fd_sc_hd__fill_2
XFILLER_11_276 VGND VGND VPWR VPWR sky130_fd_sc_hd__decap_3
XFILLER_11_298 VGND VGND VPWR VPWR sky130_fd_sc_hd__decap_3
XFILLER_7_225 VGND VGND VPWR VPWR sky130_fd_sc_hd__fill_2
XFILLER_109_164 VGND VGND VPWR VPWR sky130_fd_sc_hd__fill_1
XFILLER_50_85 VGND VGND VPWR VPWR sky130_fd_sc_hd__decap_3
XFILLER_7_269 VGND VGND VPWR VPWR sky130_fd_sc_hd__decap_3
XFILLER_109_175 VGND VGND VPWR VPWR sky130_fd_sc_hd__decap_3
XFILLER_3_420 VGND VGND VPWR VPWR sky130_fd_sc_hd__decap_3
XFILLER_79_700 VGND VGND VPWR VPWR sky130_fd_sc_hd__decap_3
XFILLER_98_508 VGND VGND VPWR VPWR sky130_fd_sc_hd__decap_3
XFILLER_105_370 VGND VGND VPWR VPWR sky130_fd_sc_hd__fill_1
XFILLER_59_50 VGND VGND VPWR VPWR sky130_fd_sc_hd__fill_2
XTAP_TAPCELL_ROW_111_1646 VGND VPWR sky130_fd_sc_hd__tapvpwrvgnd_1
XFILLER_59_83 VGND VGND VPWR VPWR sky130_fd_sc_hd__decap_3
XFILLER_38_107 VGND VGND VPWR VPWR sky130_fd_sc_hd__decap_3
XFILLER_93_202 VGND VGND VPWR VPWR sky130_fd_sc_hd__decap_3
XFILLER_47_641 VGND VGND VPWR VPWR sky130_fd_sc_hd__decap_3
XFILLER_19_354 VGND VGND VPWR VPWR sky130_fd_sc_hd__decap_3
XFILLER_75_60 VGND VGND VPWR VPWR sky130_fd_sc_hd__fill_1
XFILLER_19_376 VGND VGND VPWR VPWR sky130_fd_sc_hd__decap_3
XFILLER_46_162 VGND VGND VPWR VPWR sky130_fd_sc_hd__decap_3
XFILLER_47_685 VGND VGND VPWR VPWR sky130_fd_sc_hd__decap_3
XFILLER_61_110 VGND VGND VPWR VPWR sky130_fd_sc_hd__fill_2
XFILLER_62_611 VGND VGND VPWR VPWR sky130_fd_sc_hd__decap_3
XFILLER_75_93 VGND VGND VPWR VPWR sky130_fd_sc_hd__fill_1
XTAP_TAPCELL_ROW_45_820 VGND VPWR sky130_fd_sc_hd__tapvpwrvgnd_1
XFILLER_34_357 VGND VGND VPWR VPWR sky130_fd_sc_hd__decap_3
XFILLER_46_195 VGND VGND VPWR VPWR sky130_fd_sc_hd__fill_1
XFILLER_61_143 VGND VGND VPWR VPWR sky130_fd_sc_hd__decap_3
XFILLER_62_666 VGND VGND VPWR VPWR sky130_fd_sc_hd__decap_3
XFILLER_62_699 VGND VGND VPWR VPWR sky130_fd_sc_hd__fill_1
XFILLER_15_593 VGND VGND VPWR VPWR sky130_fd_sc_hd__decap_3
XFILLER_91_92 VGND VGND VPWR VPWR sky130_fd_sc_hd__decap_3
X_5690_ _7351_/Q _6695_/Q _5708_/S VGND VGND VPWR VPWR _6695_/D sky130_fd_sc_hd__mux2_2
X_4710_ _7004_/Q _4801_/A VGND VGND VPWR VPWR _4775_/A sky130_fd_sc_hd__and2_2
X_4641_ _4920_/A _4379_/B _4640_/Y _4158_/A VGND VGND VPWR VPWR _4903_/B sky130_fd_sc_hd__o31a_2
XFILLER_30_585 VGND VGND VPWR VPWR sky130_fd_sc_hd__decap_3
XFILLER_116_613 VGND VGND VPWR VPWR sky130_fd_sc_hd__decap_3
X_7360_ _7360_/CLK _7360_/D _6640_/Y VGND VGND VPWR VPWR _7360_/Q sky130_fd_sc_hd__dfrtp_2
XTAP_TAPCELL_ROW_77_1221 VGND VPWR sky130_fd_sc_hd__tapvpwrvgnd_1
XFILLER_116_657 VGND VGND VPWR VPWR sky130_fd_sc_hd__decap_3
X_7291_ _7322_/CLK _7291_/D _6571_/Y VGND VGND VPWR VPWR _7291_/Q sky130_fd_sc_hd__dfrtp_2
Xhold704 _6937_/Q VGND VGND VPWR VPWR _6937_/D sky130_fd_sc_hd__dlygate4sd3_1
Xhold715 _6792_/Q VGND VGND VPWR VPWR _6792_/D sky130_fd_sc_hd__dlygate4sd3_1
Xhold726 _6874_/Q VGND VGND VPWR VPWR _6874_/D sky130_fd_sc_hd__dlygate4sd3_1
Xhold737 _6887_/Q VGND VGND VPWR VPWR _6887_/D sky130_fd_sc_hd__dlygate4sd3_1
X_6311_ _6624_/A VGND VGND VPWR VPWR _6311_/Y sky130_fd_sc_hd__inv_2
X_3523_ _3505_/A _3458_/Y _3505_/B _3506_/Y _3508_/A VGND VGND VPWR VPWR _3620_/A
+ sky130_fd_sc_hd__o311a_4
XFILLER_115_167 VGND VGND VPWR VPWR sky130_fd_sc_hd__fill_1
XFILLER_89_508 VGND VGND VPWR VPWR sky130_fd_sc_hd__decap_3
Xhold748 _6952_/Q VGND VGND VPWR VPWR _6952_/D sky130_fd_sc_hd__dlygate4sd3_1
Xhold759 _6765_/Q VGND VGND VPWR VPWR _6765_/D sky130_fd_sc_hd__dlygate4sd3_1
X_3454_ _7186_/Q _3996_/S _4300_/B _7031_/Q _3453_/X VGND VGND VPWR VPWR _3454_/X
+ sky130_fd_sc_hd__a221o_2
XFILLER_103_318 VGND VGND VPWR VPWR sky130_fd_sc_hd__decap_3
XFILLER_97_541 VGND VGND VPWR VPWR sky130_fd_sc_hd__decap_3
X_3385_ _6983_/Q _5130_/A VGND VGND VPWR VPWR _3385_/Y sky130_fd_sc_hd__nor2_2
XFILLER_111_362 VGND VGND VPWR VPWR sky130_fd_sc_hd__decap_3
XFILLER_69_287 VGND VGND VPWR VPWR sky130_fd_sc_hd__decap_3
XFILLER_85_703 VGND VGND VPWR VPWR sky130_fd_sc_hd__decap_3
X_5124_ _3746_/B _3900_/Y _4677_/B VGND VGND VPWR VPWR _5125_/B sky130_fd_sc_hd__a21o_2
XFILLER_57_438 VGND VGND VPWR VPWR sky130_fd_sc_hd__decap_3
XFILLER_57_449 VGND VGND VPWR VPWR sky130_fd_sc_hd__decap_3
XFILLER_84_224 VGND VGND VPWR VPWR sky130_fd_sc_hd__decap_3
X_5055_ _4811_/C _5049_/X _5053_/Y _5054_/Y _4369_/A VGND VGND VPWR VPWR _5055_/X
+ sky130_fd_sc_hd__a221o_2
XFILLER_38_663 VGND VGND VPWR VPWR sky130_fd_sc_hd__decap_3
XFILLER_37_162 VGND VGND VPWR VPWR sky130_fd_sc_hd__decap_3
XFILLER_38_696 VGND VGND VPWR VPWR sky130_fd_sc_hd__decap_3
XFILLER_65_482 VGND VGND VPWR VPWR sky130_fd_sc_hd__decap_3
XTAP_TAPCELL_ROW_88_1361 VGND VPWR sky130_fd_sc_hd__tapvpwrvgnd_1
XFILLER_111_36 VGND VGND VPWR VPWR sky130_fd_sc_hd__decap_3
XFILLER_25_357 VGND VGND VPWR VPWR sky130_fd_sc_hd__decap_3
XFILLER_52_132 VGND VGND VPWR VPWR sky130_fd_sc_hd__decap_3
XFILLER_53_644 VGND VGND VPWR VPWR sky130_fd_sc_hd__decap_3
XFILLER_111_69 VGND VGND VPWR VPWR sky130_fd_sc_hd__decap_3
XFILLER_13_508 VGND VGND VPWR VPWR sky130_fd_sc_hd__decap_3
XFILLER_13_519 VGND VGND VPWR VPWR sky130_fd_sc_hd__decap_3
XFILLER_52_165 VGND VGND VPWR VPWR sky130_fd_sc_hd__decap_3
XFILLER_53_688 VGND VGND VPWR VPWR sky130_fd_sc_hd__decap_3
XFILLER_80_463 VGND VGND VPWR VPWR sky130_fd_sc_hd__decap_3
XFILLER_33_390 VGND VGND VPWR VPWR sky130_fd_sc_hd__fill_2
X_4908_ _4908_/A _4908_/B VGND VGND VPWR VPWR _4909_/C sky130_fd_sc_hd__nor2_2
XTAP_TAPCELL_ROW_23_547 VGND VPWR sky130_fd_sc_hd__tapvpwrvgnd_1
X_4839_ _4916_/A _4916_/B _4634_/Y VGND VGND VPWR VPWR _4903_/C sky130_fd_sc_hd__a21o_2
XFILLER_107_613 VGND VGND VPWR VPWR sky130_fd_sc_hd__decap_3
XTAP_TAPCELL_ROW_99_1490 VGND VPWR sky130_fd_sc_hd__tapvpwrvgnd_1
XFILLER_106_101 VGND VGND VPWR VPWR sky130_fd_sc_hd__decap_3
XFILLER_107_635 VGND VGND VPWR VPWR sky130_fd_sc_hd__decap_3
XFILLER_112_6 VGND VGND VPWR VPWR sky130_fd_sc_hd__decap_3
X_6509_ _6641_/A VGND VGND VPWR VPWR _6509_/Y sky130_fd_sc_hd__inv_2
XFILLER_106_134 VGND VGND VPWR VPWR sky130_fd_sc_hd__decap_3
XFILLER_107_668 VGND VGND VPWR VPWR sky130_fd_sc_hd__decap_3
XFILLER_107_679 VGND VGND VPWR VPWR sky130_fd_sc_hd__decap_3
XFILLER_0_445 VGND VGND VPWR VPWR sky130_fd_sc_hd__decap_3
XFILLER_88_530 VGND VGND VPWR VPWR sky130_fd_sc_hd__fill_2
XFILLER_88_541 VGND VGND VPWR VPWR sky130_fd_sc_hd__decap_3
XFILLER_0_489 VGND VGND VPWR VPWR sky130_fd_sc_hd__fill_1
XFILLER_102_351 VGND VGND VPWR VPWR sky130_fd_sc_hd__decap_3
XFILLER_75_202 VGND VGND VPWR VPWR sky130_fd_sc_hd__decap_3
XFILLER_75_246 VGND VGND VPWR VPWR sky130_fd_sc_hd__decap_3
XFILLER_29_641 VGND VGND VPWR VPWR sky130_fd_sc_hd__decap_3
XFILLER_63_419 VGND VGND VPWR VPWR sky130_fd_sc_hd__decap_3
XFILLER_75_268 VGND VGND VPWR VPWR sky130_fd_sc_hd__decap_3
XFILLER_91_706 VGND VGND VPWR VPWR sky130_fd_sc_hd__decap_3
XFILLER_28_162 VGND VGND VPWR VPWR sky130_fd_sc_hd__decap_3
XFILLER_29_685 VGND VGND VPWR VPWR sky130_fd_sc_hd__decap_3
XFILLER_44_622 VGND VGND VPWR VPWR sky130_fd_sc_hd__decap_3
XFILLER_90_227 VGND VGND VPWR VPWR sky130_fd_sc_hd__decap_3
Xplace419 _4265_/B VGND VGND VPWR VPWR _4102_/B sky130_fd_sc_hd__buf_2
Xplace408 _5028_/S VGND VGND VPWR VPWR _4979_/S sky130_fd_sc_hd__buf_2
XTAP_TAPCELL_ROW_3_294 VGND VPWR sky130_fd_sc_hd__tapvpwrvgnd_1
XFILLER_43_110 VGND VGND VPWR VPWR sky130_fd_sc_hd__fill_2
XFILLER_44_666 VGND VGND VPWR VPWR sky130_fd_sc_hd__decap_3
XFILLER_45_63 VGND VGND VPWR VPWR sky130_fd_sc_hd__decap_3
XFILLER_90_249 VGND VGND VPWR VPWR sky130_fd_sc_hd__decap_3
XFILLER_44_699 VGND VGND VPWR VPWR sky130_fd_sc_hd__fill_1
XTAP_TAPCELL_ROW_61_1022 VGND VPWR sky130_fd_sc_hd__tapvpwrvgnd_1
XFILLER_12_563 VGND VGND VPWR VPWR sky130_fd_sc_hd__decap_3
XFILLER_8_545 VGND VGND VPWR VPWR sky130_fd_sc_hd__decap_3
XFILLER_8_578 VGND VGND VPWR VPWR sky130_fd_sc_hd__decap_3
XFILLER_8_589 VGND VGND VPWR VPWR sky130_fd_sc_hd__decap_3
XANTENNA_6 _5634_/B VGND VGND VPWR VPWR sky130_fd_sc_hd__diode_2
XFILLER_113_638 VGND VGND VPWR VPWR sky130_fd_sc_hd__decap_3
XFILLER_3_261 VGND VGND VPWR VPWR sky130_fd_sc_hd__decap_3
XFILLER_106_690 VGND VGND VPWR VPWR sky130_fd_sc_hd__decap_3
XFILLER_112_137 VGND VGND VPWR VPWR sky130_fd_sc_hd__decap_3
XFILLER_79_541 VGND VGND VPWR VPWR sky130_fd_sc_hd__decap_3
XFILLER_67_703 VGND VGND VPWR VPWR sky130_fd_sc_hd__decap_3
XTAP_TAPCELL_ROW_72_1162 VGND VPWR sky130_fd_sc_hd__tapvpwrvgnd_1
XFILLER_39_449 VGND VGND VPWR VPWR sky130_fd_sc_hd__fill_2
XFILLER_66_224 VGND VGND VPWR VPWR sky130_fd_sc_hd__decap_3
XFILLER_86_70 VGND VGND VPWR VPWR sky130_fd_sc_hd__decap_3
XFILLER_54_408 VGND VGND VPWR VPWR sky130_fd_sc_hd__decap_3
XFILLER_66_257 VGND VGND VPWR VPWR sky130_fd_sc_hd__decap_3
XFILLER_94_577 VGND VGND VPWR VPWR sky130_fd_sc_hd__decap_3
XFILLER_35_600 VGND VGND VPWR VPWR sky130_fd_sc_hd__decap_3
XFILLER_35_644 VGND VGND VPWR VPWR sky130_fd_sc_hd__decap_3
XFILLER_62_430 VGND VGND VPWR VPWR sky130_fd_sc_hd__decap_3
X_6860_ clkload9/A _6860_/D VGND VGND VPWR VPWR _6860_/Q sky130_fd_sc_hd__dfxtp_2
XFILLER_34_165 VGND VGND VPWR VPWR sky130_fd_sc_hd__fill_1
XFILLER_35_688 VGND VGND VPWR VPWR sky130_fd_sc_hd__decap_3
XFILLER_50_614 VGND VGND VPWR VPWR sky130_fd_sc_hd__decap_3
XFILLER_62_463 VGND VGND VPWR VPWR sky130_fd_sc_hd__decap_3
X_6791_ _6942_/CLK _6791_/D VGND VGND VPWR VPWR _6791_/Q sky130_fd_sc_hd__dfxtp_2
XFILLER_22_327 VGND VGND VPWR VPWR sky130_fd_sc_hd__decap_3
XFILLER_22_349 VGND VGND VPWR VPWR sky130_fd_sc_hd__decap_3
XTAP_TAPCELL_ROW_83_1291 VGND VPWR sky130_fd_sc_hd__tapvpwrvgnd_1
XFILLER_50_669 VGND VGND VPWR VPWR sky130_fd_sc_hd__decap_3
XTAP_TAPCELL_ROW_20_506 VGND VPWR sky130_fd_sc_hd__tapvpwrvgnd_1
XFILLER_30_360 VGND VGND VPWR VPWR sky130_fd_sc_hd__decap_3
XFILLER_30_382 VGND VGND VPWR VPWR sky130_fd_sc_hd__decap_3
X_7412_ _7412_/A VGND VGND VPWR VPWR _7412_/X sky130_fd_sc_hd__buf_2
X_4624_ _4624_/A _4624_/B VGND VGND VPWR VPWR _4624_/X sky130_fd_sc_hd__and2_2
XPHY_EDGE_ROW_6_Right_6 VGND VGND VPWR VPWR sky130_fd_sc_hd__decap_3
XFILLER_116_432 VGND VGND VPWR VPWR sky130_fd_sc_hd__decap_3
X_7343_ _7344_/CLK _7343_/D _6623_/Y VGND VGND VPWR VPWR _7343_/Q sky130_fd_sc_hd__dfrtp_2
X_3506_ _3544_/A _3506_/B VGND VGND VPWR VPWR _3506_/Y sky130_fd_sc_hd__nand2_2
XFILLER_104_616 VGND VGND VPWR VPWR sky130_fd_sc_hd__decap_3
XFILLER_116_487 VGND VGND VPWR VPWR sky130_fd_sc_hd__decap_3
XFILLER_116_498 VGND VGND VPWR VPWR sky130_fd_sc_hd__decap_3
XFILLER_89_316 VGND VGND VPWR VPWR sky130_fd_sc_hd__decap_3
X_7274_ _7402_/CLK _7274_/D _6554_/Y VGND VGND VPWR VPWR _7274_/Q sky130_fd_sc_hd__dfrtp_2
X_4486_ _4486_/A0 _7304_/Q _4497_/S VGND VGND VPWR VPWR _7336_/D sky130_fd_sc_hd__mux2_2
XFILLER_103_137 VGND VGND VPWR VPWR sky130_fd_sc_hd__decap_3
XFILLER_106_14 VGND VGND VPWR VPWR sky130_fd_sc_hd__decap_3
XFILLER_112_660 VGND VGND VPWR VPWR sky130_fd_sc_hd__decap_3
XFILLER_85_511 VGND VGND VPWR VPWR sky130_fd_sc_hd__decap_3
XFILLER_97_360 VGND VGND VPWR VPWR sky130_fd_sc_hd__decap_3
X_3368_ _3340_/A _5294_/A _3310_/Y _6983_/Q VGND VGND VPWR VPWR _3368_/Y sky130_fd_sc_hd__a211oi_4
XFILLER_112_693 VGND VGND VPWR VPWR sky130_fd_sc_hd__decap_3
XFILLER_66_29 VGND VGND VPWR VPWR sky130_fd_sc_hd__decap_3
XFILLER_85_533 VGND VGND VPWR VPWR sky130_fd_sc_hd__decap_3
Xhold1201 _7152_/Q VGND VGND VPWR VPWR _5358_/A0 sky130_fd_sc_hd__dlygate4sd3_1
Xhold1212 _7140_/Q VGND VGND VPWR VPWR _5386_/A0 sky130_fd_sc_hd__dlygate4sd3_1
Xhold1223 _7122_/Q VGND VGND VPWR VPWR _5423_/A0 sky130_fd_sc_hd__dlygate4sd3_1
Xhold1234 _7251_/Q VGND VGND VPWR VPWR _5136_/A0 sky130_fd_sc_hd__dlygate4sd3_1
X_5107_ _5156_/S _6985_/D _5105_/X _5106_/X VGND VGND VPWR VPWR _5107_/X sky130_fd_sc_hd__o22a_2
XFILLER_57_257 VGND VGND VPWR VPWR sky130_fd_sc_hd__fill_2
XFILLER_73_706 VGND VGND VPWR VPWR sky130_fd_sc_hd__decap_3
Xhold1245 _7127_/Q VGND VGND VPWR VPWR _5413_/A0 sky130_fd_sc_hd__dlygate4sd3_1
Xhold1256 _7286_/Q VGND VGND VPWR VPWR _4589_/A sky130_fd_sc_hd__dlygate4sd3_1
Xhold1267 _7168_/Q VGND VGND VPWR VPWR _5325_/A0 sky130_fd_sc_hd__dlygate4sd3_1
X_3299_ _3327_/B _5129_/B _3324_/A VGND VGND VPWR VPWR _3328_/A sky130_fd_sc_hd__o21a_2
XTAP_TAPCELL_ROW_28_606 VGND VPWR sky130_fd_sc_hd__tapvpwrvgnd_1
XFILLER_26_622 VGND VGND VPWR VPWR sky130_fd_sc_hd__decap_3
XFILLER_38_471 VGND VGND VPWR VPWR sky130_fd_sc_hd__decap_3
XFILLER_72_216 VGND VGND VPWR VPWR sky130_fd_sc_hd__decap_3
Xhold1278 _7147_/Q VGND VGND VPWR VPWR _5371_/A0 sky130_fd_sc_hd__dlygate4sd3_1
Xhold1289 _7400_/Q VGND VGND VPWR VPWR _3705_/A0 sky130_fd_sc_hd__dlygate4sd3_1
X_5038_ _5038_/A _5038_/B VGND VGND VPWR VPWR _5038_/X sky130_fd_sc_hd__xor2_2
XFILLER_26_666 VGND VGND VPWR VPWR sky130_fd_sc_hd__decap_3
XFILLER_38_493 VGND VGND VPWR VPWR sky130_fd_sc_hd__fill_2
XTAP_TAPCELL_ROW_56_959 VGND VPWR sky130_fd_sc_hd__tapvpwrvgnd_1
XTAP_TAPCELL_ROW_0_253 VGND VPWR sky130_fd_sc_hd__tapvpwrvgnd_1
XTAP_TAPCELL_ROW_0_242 VGND VPWR sky130_fd_sc_hd__tapvpwrvgnd_1
XFILLER_13_316 VGND VGND VPWR VPWR sky130_fd_sc_hd__decap_3
XFILLER_15_11 VGND VGND VPWR VPWR sky130_fd_sc_hd__fill_2
XFILLER_25_165 VGND VGND VPWR VPWR sky130_fd_sc_hd__decap_3
XFILLER_25_176 VGND VGND VPWR VPWR sky130_fd_sc_hd__decap_3
XFILLER_26_699 VGND VGND VPWR VPWR sky130_fd_sc_hd__fill_1
XFILLER_41_603 VGND VGND VPWR VPWR sky130_fd_sc_hd__decap_3
XTAP_TAPCELL_ROW_0_264 VGND VPWR sky130_fd_sc_hd__tapvpwrvgnd_1
XFILLER_15_33 VGND VGND VPWR VPWR sky130_fd_sc_hd__decap_3
XFILLER_40_113 VGND VGND VPWR VPWR sky130_fd_sc_hd__fill_2
XFILLER_41_647 VGND VGND VPWR VPWR sky130_fd_sc_hd__decap_3
X_6989_ _7396_/CLK _6989_/D _6269_/Y VGND VGND VPWR VPWR _6989_/Q sky130_fd_sc_hd__dfrtp_2
XFILLER_15_99 VGND VGND VPWR VPWR sky130_fd_sc_hd__decap_3
XFILLER_40_157 VGND VGND VPWR VPWR sky130_fd_sc_hd__decap_3
XFILLER_21_371 VGND VGND VPWR VPWR sky130_fd_sc_hd__decap_3
XFILLER_21_393 VGND VGND VPWR VPWR sky130_fd_sc_hd__decap_3
XFILLER_107_421 VGND VGND VPWR VPWR sky130_fd_sc_hd__decap_3
XFILLER_119_281 VGND VGND VPWR VPWR sky130_fd_sc_hd__decap_3
XFILLER_107_432 VGND VGND VPWR VPWR sky130_fd_sc_hd__decap_3
XFILLER_5_548 VGND VGND VPWR VPWR sky130_fd_sc_hd__decap_3
XFILLER_107_476 VGND VGND VPWR VPWR sky130_fd_sc_hd__decap_3
XTAP_TAPCELL_ROW_8_353 VGND VPWR sky130_fd_sc_hd__tapvpwrvgnd_1
XFILLER_0_264 VGND VGND VPWR VPWR sky130_fd_sc_hd__decap_3
XFILLER_103_671 VGND VGND VPWR VPWR sky130_fd_sc_hd__fill_1
XFILLER_110_619 VGND VGND VPWR VPWR sky130_fd_sc_hd__decap_3
XFILLER_49_703 VGND VGND VPWR VPWR sky130_fd_sc_hd__decap_3
XFILLER_95_308 VGND VGND VPWR VPWR sky130_fd_sc_hd__decap_3
XTAP_TAPCELL_ROW_8_364 VGND VPWR sky130_fd_sc_hd__tapvpwrvgnd_1
XFILLER_103_682 VGND VGND VPWR VPWR sky130_fd_sc_hd__decap_3
XFILLER_48_213 VGND VGND VPWR VPWR sky130_fd_sc_hd__decap_3
XFILLER_88_371 VGND VGND VPWR VPWR sky130_fd_sc_hd__decap_3
XFILLER_102_192 VGND VGND VPWR VPWR sky130_fd_sc_hd__decap_3
XFILLER_48_246 VGND VGND VPWR VPWR sky130_fd_sc_hd__decap_3
XFILLER_48_268 VGND VGND VPWR VPWR sky130_fd_sc_hd__decap_3
XFILLER_17_611 VGND VGND VPWR VPWR sky130_fd_sc_hd__decap_3
XFILLER_29_482 VGND VGND VPWR VPWR sky130_fd_sc_hd__decap_3
XFILLER_63_216 VGND VGND VPWR VPWR sky130_fd_sc_hd__decap_3
XFILLER_16_121 VGND VGND VPWR VPWR sky130_fd_sc_hd__decap_3
XFILLER_17_644 VGND VGND VPWR VPWR sky130_fd_sc_hd__decap_3
XFILLER_56_290 VGND VGND VPWR VPWR sky130_fd_sc_hd__decap_3
XFILLER_17_688 VGND VGND VPWR VPWR sky130_fd_sc_hd__decap_3
XFILLER_44_474 VGND VGND VPWR VPWR sky130_fd_sc_hd__fill_2
XTAP_TAPCELL_ROW_106_1578 VGND VPWR sky130_fd_sc_hd__tapvpwrvgnd_1
XFILLER_31_113 VGND VGND VPWR VPWR sky130_fd_sc_hd__fill_1
XFILLER_32_625 VGND VGND VPWR VPWR sky130_fd_sc_hd__decap_3
XTAP_TAPCELL_ROW_106_1589 VGND VPWR sky130_fd_sc_hd__tapvpwrvgnd_1
XFILLER_32_669 VGND VGND VPWR VPWR sky130_fd_sc_hd__decap_3
XFILLER_72_83 VGND VGND VPWR VPWR sky130_fd_sc_hd__fill_1
XFILLER_12_360 VGND VGND VPWR VPWR sky130_fd_sc_hd__decap_3
XFILLER_12_371 VGND VGND VPWR VPWR sky130_fd_sc_hd__fill_1
XPHY_EDGE_ROW_59_Right_59 VGND VGND VPWR VPWR sky130_fd_sc_hd__decap_3
XFILLER_117_207 VGND VGND VPWR VPWR sky130_fd_sc_hd__decap_3
XFILLER_12_393 VGND VGND VPWR VPWR sky130_fd_sc_hd__decap_3
XFILLER_75_6 VGND VGND VPWR VPWR sky130_fd_sc_hd__decap_3
XFILLER_8_342 VGND VGND VPWR VPWR sky130_fd_sc_hd__fill_2
XFILLER_117_218 VGND VGND VPWR VPWR sky130_fd_sc_hd__decap_3
Xoutput617 _4528_/B VGND VGND VPWR VPWR instruction_out[24] sky130_fd_sc_hd__clkdlybuf4s25_1
Xoutput606 _5645_/X VGND VGND VPWR VPWR instruction_out[12] sky130_fd_sc_hd__clkdlybuf4s25_1
XFILLER_98_102 VGND VGND VPWR VPWR sky130_fd_sc_hd__decap_3
Xoutput639 _6994_/Q VGND VGND VPWR VPWR pc_out[17] sky130_fd_sc_hd__clkdlybuf4s25_1
Xoutput628 _5229_/B VGND VGND VPWR VPWR instruction_out[7] sky130_fd_sc_hd__clkdlybuf4s25_1
X_4340_ _7223_/Q _4349_/B1 _4338_/X _4339_/X VGND VGND VPWR VPWR _4340_/X sky130_fd_sc_hd__a211o_2
XFILLER_113_446 VGND VGND VPWR VPWR sky130_fd_sc_hd__fill_2
XFILLER_4_581 VGND VGND VPWR VPWR sky130_fd_sc_hd__decap_3
XFILLER_98_135 VGND VGND VPWR VPWR sky130_fd_sc_hd__decap_3
X_4271_ _4271_/A _4271_/B _4271_/C _4270_/Y VGND VGND VPWR VPWR _4271_/X sky130_fd_sc_hd__or4b_2
XFILLER_99_647 VGND VGND VPWR VPWR sky130_fd_sc_hd__decap_3
XFILLER_97_80 VGND VGND VPWR VPWR sky130_fd_sc_hd__decap_3
XFILLER_98_179 VGND VGND VPWR VPWR sky130_fd_sc_hd__decap_3
XPHY_EDGE_ROW_68_Right_68 VGND VGND VPWR VPWR sky130_fd_sc_hd__decap_3
XFILLER_39_246 VGND VGND VPWR VPWR sky130_fd_sc_hd__decap_3
XFILLER_55_706 VGND VGND VPWR VPWR sky130_fd_sc_hd__decap_3
XFILLER_67_555 VGND VGND VPWR VPWR sky130_fd_sc_hd__fill_2
XFILLER_94_352 VGND VGND VPWR VPWR sky130_fd_sc_hd__decap_3
XFILLER_54_227 VGND VGND VPWR VPWR sky130_fd_sc_hd__decap_3
XFILLER_82_525 VGND VGND VPWR VPWR sky130_fd_sc_hd__decap_3
XFILLER_82_536 VGND VGND VPWR VPWR sky130_fd_sc_hd__fill_1
XPHY_EDGE_ROW_6_Left_126 VGND VGND VPWR VPWR sky130_fd_sc_hd__decap_3
XFILLER_54_238 VGND VGND VPWR VPWR sky130_fd_sc_hd__decap_3
X_6912_ _6942_/CLK _6912_/D VGND VGND VPWR VPWR _6912_/Q sky130_fd_sc_hd__dfxtp_2
XTAP_TAPCELL_ROW_85_1320 VGND VPWR sky130_fd_sc_hd__tapvpwrvgnd_1
XFILLER_23_603 VGND VGND VPWR VPWR sky130_fd_sc_hd__decap_3
XFILLER_35_452 VGND VGND VPWR VPWR sky130_fd_sc_hd__fill_1
X_6843_ clkload6/A _6843_/D VGND VGND VPWR VPWR _6843_/Q sky130_fd_sc_hd__dfxtp_2
XTAP_TAPCELL_ROW_53_918 VGND VPWR sky130_fd_sc_hd__tapvpwrvgnd_1
XFILLER_23_647 VGND VGND VPWR VPWR sky130_fd_sc_hd__decap_3
X_6774_ _6906_/CLK _6774_/D VGND VGND VPWR VPWR _6774_/Q sky130_fd_sc_hd__dfxtp_2
XPHY_EDGE_ROW_77_Right_77 VGND VGND VPWR VPWR sky130_fd_sc_hd__decap_3
X_5725_ _7368_/Q _5725_/A1 _5735_/S VGND VGND VPWR VPWR _6712_/D sky130_fd_sc_hd__mux2_2
XTAP_TAPCELL_ROW_33_675 VGND VPWR sky130_fd_sc_hd__tapvpwrvgnd_1
XFILLER_30_190 VGND VGND VPWR VPWR sky130_fd_sc_hd__decap_3
XFILLER_31_691 VGND VGND VPWR VPWR sky130_fd_sc_hd__decap_3
X_5656_ _5656_/A _5656_/B _5656_/C VGND VGND VPWR VPWR _5665_/C sky130_fd_sc_hd__nor3_2
XFILLER_108_218 VGND VGND VPWR VPWR sky130_fd_sc_hd__decap_3
X_5587_ _5587_/A _5587_/B VGND VGND VPWR VPWR _7034_/D sky130_fd_sc_hd__and2_2
XTAP_TAPCELL_ROW_96_1460 VGND VPWR sky130_fd_sc_hd__tapvpwrvgnd_1
XFILLER_116_273 VGND VGND VPWR VPWR sky130_fd_sc_hd__decap_3
XFILLER_117_35 VGND VGND VPWR VPWR sky130_fd_sc_hd__decap_3
XFILLER_2_507 VGND VGND VPWR VPWR sky130_fd_sc_hd__decap_3
XFILLER_89_113 VGND VGND VPWR VPWR sky130_fd_sc_hd__decap_3
X_7326_ _7360_/CLK _7326_/D _6606_/Y VGND VGND VPWR VPWR _7326_/Q sky130_fd_sc_hd__dfrtp_2
XFILLER_104_424 VGND VGND VPWR VPWR sky130_fd_sc_hd__decap_3
XFILLER_117_57 VGND VGND VPWR VPWR sky130_fd_sc_hd__decap_3
XFILLER_89_146 VGND VGND VPWR VPWR sky130_fd_sc_hd__fill_2
X_7257_ _7354_/CLK _7257_/D _6537_/Y VGND VGND VPWR VPWR _7257_/Q sky130_fd_sc_hd__dfrtp_2
X_4469_ _7009_/Q _4467_/A _3318_/B _4468_/X VGND VGND VPWR VPWR _4469_/X sky130_fd_sc_hd__a31o_2
XFILLER_104_468 VGND VGND VPWR VPWR sky130_fd_sc_hd__decap_3
XFILLER_77_319 VGND VGND VPWR VPWR sky130_fd_sc_hd__decap_3
XFILLER_77_39 VGND VGND VPWR VPWR sky130_fd_sc_hd__fill_1
XPHY_EDGE_ROW_86_Right_86 VGND VGND VPWR VPWR sky130_fd_sc_hd__decap_3
XFILLER_58_533 VGND VGND VPWR VPWR sky130_fd_sc_hd__fill_2
X_7188_ _7189_/CLK _7188_/D _6468_/Y VGND VGND VPWR VPWR _7188_/Q sky130_fd_sc_hd__dfrtp_2
XTAP_TAPCELL_ROW_5_323 VGND VPWR sky130_fd_sc_hd__tapvpwrvgnd_1
XFILLER_100_641 VGND VGND VPWR VPWR sky130_fd_sc_hd__decap_3
XFILLER_100_663 VGND VGND VPWR VPWR sky130_fd_sc_hd__decap_3
XFILLER_112_490 VGND VGND VPWR VPWR sky130_fd_sc_hd__decap_3
Xhold1020 _6698_/Q VGND VGND VPWR VPWR _5697_/A1 sky130_fd_sc_hd__dlygate4sd3_1
Xhold1031 _7049_/Q VGND VGND VPWR VPWR _5568_/A1 sky130_fd_sc_hd__dlygate4sd3_1
Xhold1042 _7395_/Q VGND VGND VPWR VPWR _3763_/A1 sky130_fd_sc_hd__dlygate4sd3_1
XFILLER_100_696 VGND VGND VPWR VPWR sky130_fd_sc_hd__decap_3
XFILLER_18_419 VGND VGND VPWR VPWR sky130_fd_sc_hd__fill_1
XFILLER_73_503 VGND VGND VPWR VPWR sky130_fd_sc_hd__fill_1
XFILLER_85_396 VGND VGND VPWR VPWR sky130_fd_sc_hd__decap_3
Xhold1053 _7027_/Q VGND VGND VPWR VPWR _5600_/A sky130_fd_sc_hd__dlygate4sd3_1
Xhold1064 _7053_/Q VGND VGND VPWR VPWR _5563_/A1 sky130_fd_sc_hd__dlygate4sd3_1
Xhold1075 _7211_/Q VGND VGND VPWR VPWR _5239_/A1 sky130_fd_sc_hd__dlygate4sd3_1
XFILLER_38_290 VGND VGND VPWR VPWR sky130_fd_sc_hd__fill_2
XFILLER_61_709 VGND VGND VPWR VPWR sky130_fd_sc_hd__decap_3
Xhold1086 _7401_/Q VGND VGND VPWR VPWR _3702_/A1 sky130_fd_sc_hd__dlygate4sd3_1
Xhold1097 _7199_/Q VGND VGND VPWR VPWR _5262_/A0 sky130_fd_sc_hd__dlygate4sd3_1
XFILLER_26_452 VGND VGND VPWR VPWR sky130_fd_sc_hd__decap_3
XFILLER_26_474 VGND VGND VPWR VPWR sky130_fd_sc_hd__fill_2
XFILLER_14_625 VGND VGND VPWR VPWR sky130_fd_sc_hd__decap_3
XPHY_EDGE_ROW_95_Right_95 VGND VGND VPWR VPWR sky130_fd_sc_hd__decap_3
XFILLER_14_669 VGND VGND VPWR VPWR sky130_fd_sc_hd__decap_3
XFILLER_41_455 VGND VGND VPWR VPWR sky130_fd_sc_hd__decap_3
XFILLER_5_323 VGND VGND VPWR VPWR sky130_fd_sc_hd__fill_2
XFILLER_107_240 VGND VGND VPWR VPWR sky130_fd_sc_hd__decap_3
XFILLER_107_262 VGND VGND VPWR VPWR sky130_fd_sc_hd__decap_3
XFILLER_5_367 VGND VGND VPWR VPWR sky130_fd_sc_hd__decap_3
XFILLER_5_389 VGND VGND VPWR VPWR sky130_fd_sc_hd__decap_3
XFILLER_107_284 VGND VGND VPWR VPWR sky130_fd_sc_hd__decap_3
XFILLER_110_405 VGND VGND VPWR VPWR sky130_fd_sc_hd__decap_3
XFILLER_68_319 VGND VGND VPWR VPWR sky130_fd_sc_hd__decap_3
XFILLER_96_628 VGND VGND VPWR VPWR sky130_fd_sc_hd__decap_3
XFILLER_107_90 VGND VGND VPWR VPWR sky130_fd_sc_hd__decap_3
XFILLER_1_573 VGND VGND VPWR VPWR sky130_fd_sc_hd__decap_3
XFILLER_49_511 VGND VGND VPWR VPWR sky130_fd_sc_hd__decap_3
XFILLER_89_691 VGND VGND VPWR VPWR sky130_fd_sc_hd__decap_3
XFILLER_95_116 VGND VGND VPWR VPWR sky130_fd_sc_hd__decap_3
XPHY_EDGE_ROW_79_Left_199 VGND VGND VPWR VPWR sky130_fd_sc_hd__decap_3
XFILLER_37_706 VGND VGND VPWR VPWR sky130_fd_sc_hd__decap_3
XFILLER_49_544 VGND VGND VPWR VPWR sky130_fd_sc_hd__decap_3
XFILLER_76_341 VGND VGND VPWR VPWR sky130_fd_sc_hd__fill_2
XFILLER_95_149 VGND VGND VPWR VPWR sky130_fd_sc_hd__decap_3
XFILLER_64_503 VGND VGND VPWR VPWR sky130_fd_sc_hd__decap_3
XFILLER_64_525 VGND VGND VPWR VPWR sky130_fd_sc_hd__decap_3
XFILLER_76_363 VGND VGND VPWR VPWR sky130_fd_sc_hd__fill_1
XFILLER_91_300 VGND VGND VPWR VPWR sky130_fd_sc_hd__decap_3
XTAP_TAPCELL_ROW_108_1607 VGND VPWR sky130_fd_sc_hd__tapvpwrvgnd_1
XFILLER_29_290 VGND VGND VPWR VPWR sky130_fd_sc_hd__decap_3
XFILLER_36_249 VGND VGND VPWR VPWR sky130_fd_sc_hd__decap_3
XFILLER_64_536 VGND VGND VPWR VPWR sky130_fd_sc_hd__fill_2
XFILLER_91_333 VGND VGND VPWR VPWR sky130_fd_sc_hd__decap_3
XFILLER_17_452 VGND VGND VPWR VPWR sky130_fd_sc_hd__fill_1
XFILLER_17_474 VGND VGND VPWR VPWR sky130_fd_sc_hd__decap_3
XFILLER_51_208 VGND VGND VPWR VPWR sky130_fd_sc_hd__decap_3
XFILLER_83_60 VGND VGND VPWR VPWR sky130_fd_sc_hd__decap_3
XFILLER_91_366 VGND VGND VPWR VPWR sky130_fd_sc_hd__decap_3
XFILLER_32_400 VGND VGND VPWR VPWR sky130_fd_sc_hd__decap_3
XFILLER_44_282 VGND VGND VPWR VPWR sky130_fd_sc_hd__decap_3
XFILLER_83_93 VGND VGND VPWR VPWR sky130_fd_sc_hd__decap_3
XTAP_TAPCELL_ROW_67_1094 VGND VPWR sky130_fd_sc_hd__tapvpwrvgnd_1
XFILLER_32_466 VGND VGND VPWR VPWR sky130_fd_sc_hd__decap_3
X_3840_ _6835_/Q _3840_/A2 _3850_/B1 _6840_/Q VGND VGND VPWR VPWR _3840_/X sky130_fd_sc_hd__a22o_2
XFILLER_20_628 VGND VGND VPWR VPWR sky130_fd_sc_hd__decap_3
X_3771_ _6910_/Q _3912_/A2 _3913_/A2 _6862_/Q VGND VGND VPWR VPWR _3771_/X sky130_fd_sc_hd__a22o_2
XTAP_TAPCELL_ROW_80_1261 VGND VPWR sky130_fd_sc_hd__tapvpwrvgnd_1
XFILLER_13_691 VGND VGND VPWR VPWR sky130_fd_sc_hd__decap_3
XTAP_TAPCELL_ROW_30_634 VGND VPWR sky130_fd_sc_hd__tapvpwrvgnd_1
XFILLER_9_662 VGND VGND VPWR VPWR sky130_fd_sc_hd__decap_3
X_6490_ _6647_/A VGND VGND VPWR VPWR _6490_/Y sky130_fd_sc_hd__inv_2
XTAP_TAPCELL_ROW_119_1758 VGND VPWR sky130_fd_sc_hd__tapvpwrvgnd_1
XTAP_TAPCELL_ROW_119_1747 VGND VPWR sky130_fd_sc_hd__tapvpwrvgnd_1
XFILLER_9_673 VGND VGND VPWR VPWR sky130_fd_sc_hd__decap_3
XFILLER_8_194 VGND VGND VPWR VPWR sky130_fd_sc_hd__fill_2
XTAP_TAPCELL_ROW_10_380 VGND VPWR sky130_fd_sc_hd__tapvpwrvgnd_1
XFILLER_99_400 VGND VGND VPWR VPWR sky130_fd_sc_hd__decap_3
X_7111_ _7371_/CLK _7111_/D _6391_/Y VGND VGND VPWR VPWR _7111_/Q sky130_fd_sc_hd__dfrtp_2
X_4323_ _7226_/Q _3318_/B _3966_/S _7194_/Q VGND VGND VPWR VPWR _4323_/X sky130_fd_sc_hd__a22o_2
XFILLER_99_433 VGND VGND VPWR VPWR sky130_fd_sc_hd__decap_3
XFILLER_87_628 VGND VGND VPWR VPWR sky130_fd_sc_hd__decap_3
X_7042_ _7358_/CLK _7042_/D _6322_/Y VGND VGND VPWR VPWR _7042_/Q sky130_fd_sc_hd__dfrtp_2
XFILLER_99_455 VGND VGND VPWR VPWR sky130_fd_sc_hd__decap_3
XFILLER_86_138 VGND VGND VPWR VPWR sky130_fd_sc_hd__fill_2
X_4254_ _7229_/Q _4353_/A2 _4269_/B1 _7042_/Q _4253_/X VGND VGND VPWR VPWR _4254_/X
+ sky130_fd_sc_hd__a221o_2
XTAP_TAPCELL_ROW_91_1390 VGND VPWR sky130_fd_sc_hd__tapvpwrvgnd_1
XFILLER_101_449 VGND VGND VPWR VPWR sky130_fd_sc_hd__fill_1
XFILLER_95_650 VGND VGND VPWR VPWR sky130_fd_sc_hd__decap_3
X_4185_ _4289_/A _5737_/S _4185_/C VGND VGND VPWR VPWR _4636_/B sky130_fd_sc_hd__and3_2
XFILLER_27_216 VGND VGND VPWR VPWR sky130_fd_sc_hd__decap_3
XFILLER_55_514 VGND VGND VPWR VPWR sky130_fd_sc_hd__decap_3
XFILLER_95_694 VGND VGND VPWR VPWR sky130_fd_sc_hd__decap_3
XFILLER_27_249 VGND VGND VPWR VPWR sky130_fd_sc_hd__decap_3
XFILLER_43_709 VGND VGND VPWR VPWR sky130_fd_sc_hd__decap_3
XFILLER_55_558 VGND VGND VPWR VPWR sky130_fd_sc_hd__fill_2
XFILLER_67_396 VGND VGND VPWR VPWR sky130_fd_sc_hd__decap_3
XFILLER_94_193 VGND VGND VPWR VPWR sky130_fd_sc_hd__decap_3
XTAP_TAPCELL_ROW_38_734 VGND VPWR sky130_fd_sc_hd__tapvpwrvgnd_1
XFILLER_70_506 VGND VGND VPWR VPWR sky130_fd_sc_hd__decap_3
XFILLER_63_591 VGND VGND VPWR VPWR sky130_fd_sc_hd__fill_2
XFILLER_11_606 VGND VGND VPWR VPWR sky130_fd_sc_hd__decap_3
XFILLER_23_444 VGND VGND VPWR VPWR sky130_fd_sc_hd__decap_3
XFILLER_23_466 VGND VGND VPWR VPWR sky130_fd_sc_hd__decap_3
XFILLER_50_230 VGND VGND VPWR VPWR sky130_fd_sc_hd__decap_3
X_6826_ clkload8/A _6826_/D VGND VGND VPWR VPWR _6826_/Q sky130_fd_sc_hd__dfxtp_2
XTAP_TAPCELL_ROW_18_480 VGND VPWR sky130_fd_sc_hd__tapvpwrvgnd_1
XFILLER_11_617 VGND VGND VPWR VPWR sky130_fd_sc_hd__decap_3
X_6757_ _6968_/CLK _6757_/D VGND VGND VPWR VPWR _6757_/Q sky130_fd_sc_hd__dfxtp_2
XFILLER_109_505 VGND VGND VPWR VPWR sky130_fd_sc_hd__fill_1
XFILLER_50_296 VGND VGND VPWR VPWR sky130_fd_sc_hd__decap_3
X_5708_ _7360_/Q _5708_/A1 _5708_/S VGND VGND VPWR VPWR _6704_/D sky130_fd_sc_hd__mux2_2
X_6688_ clkload9/A _6688_/D VGND VGND VPWR VPWR _6688_/Q sky130_fd_sc_hd__dfxtp_2
XFILLER_12_56 VGND VGND VPWR VPWR sky130_fd_sc_hd__decap_3
XFILLER_105_700 VGND VGND VPWR VPWR sky130_fd_sc_hd__decap_3
XFILLER_12_89 VGND VGND VPWR VPWR sky130_fd_sc_hd__fill_2
XFILLER_104_221 VGND VGND VPWR VPWR sky130_fd_sc_hd__decap_3
XFILLER_117_582 VGND VGND VPWR VPWR sky130_fd_sc_hd__decap_3
XFILLER_2_315 VGND VGND VPWR VPWR sky130_fd_sc_hd__fill_1
XFILLER_2_326 VGND VGND VPWR VPWR sky130_fd_sc_hd__decap_3
XFILLER_5_6 VGND VGND VPWR VPWR sky130_fd_sc_hd__decap_3
XFILLER_88_49 VGND VGND VPWR VPWR sky130_fd_sc_hd__decap_3
X_7309_ _7342_/CLK _7309_/D _6589_/Y VGND VGND VPWR VPWR _7309_/Q sky130_fd_sc_hd__dfrtp_2
XFILLER_104_265 VGND VGND VPWR VPWR sky130_fd_sc_hd__decap_3
XFILLER_2_359 VGND VGND VPWR VPWR sky130_fd_sc_hd__decap_3
XFILLER_77_116 VGND VGND VPWR VPWR sky130_fd_sc_hd__decap_3
XFILLER_77_138 VGND VGND VPWR VPWR sky130_fd_sc_hd__decap_3
XFILLER_19_706 VGND VGND VPWR VPWR sky130_fd_sc_hd__decap_3
XFILLER_46_503 VGND VGND VPWR VPWR sky130_fd_sc_hd__fill_2
XFILLER_46_514 VGND VGND VPWR VPWR sky130_fd_sc_hd__decap_3
XFILLER_58_363 VGND VGND VPWR VPWR sky130_fd_sc_hd__fill_1
XFILLER_58_374 VGND VGND VPWR VPWR sky130_fd_sc_hd__decap_3
XFILLER_86_672 VGND VGND VPWR VPWR sky130_fd_sc_hd__decap_3
XFILLER_18_249 VGND VGND VPWR VPWR sky130_fd_sc_hd__decap_3
XFILLER_58_396 VGND VGND VPWR VPWR sky130_fd_sc_hd__decap_3
XFILLER_61_517 VGND VGND VPWR VPWR sky130_fd_sc_hd__decap_3
XFILLER_73_377 VGND VGND VPWR VPWR sky130_fd_sc_hd__decap_3
XFILLER_33_219 VGND VGND VPWR VPWR sky130_fd_sc_hd__decap_3
XFILLER_61_528 VGND VGND VPWR VPWR sky130_fd_sc_hd__decap_3
XFILLER_14_433 VGND VGND VPWR VPWR sky130_fd_sc_hd__decap_3
XFILLER_26_293 VGND VGND VPWR VPWR sky130_fd_sc_hd__decap_3
XTAP_TAPCELL_ROW_103_1548 VGND VPWR sky130_fd_sc_hd__tapvpwrvgnd_1
XFILLER_14_466 VGND VGND VPWR VPWR sky130_fd_sc_hd__decap_3
XFILLER_10_672 VGND VGND VPWR VPWR sky130_fd_sc_hd__decap_3
XFILLER_6_610 VGND VGND VPWR VPWR sky130_fd_sc_hd__decap_3
XFILLER_6_643 VGND VGND VPWR VPWR sky130_fd_sc_hd__fill_1
XFILLER_6_654 VGND VGND VPWR VPWR sky130_fd_sc_hd__decap_3
XFILLER_115_508 VGND VGND VPWR VPWR sky130_fd_sc_hd__decap_3
XFILLER_6_687 VGND VGND VPWR VPWR sky130_fd_sc_hd__decap_3
XFILLER_111_703 VGND VGND VPWR VPWR sky130_fd_sc_hd__decap_3
XFILLER_69_617 VGND VGND VPWR VPWR sky130_fd_sc_hd__decap_3
XTAP_TAPCELL_ROW_114_1688 VGND VPWR sky130_fd_sc_hd__tapvpwrvgnd_1
XTAP_TAPCELL_ROW_114_1677 VGND VPWR sky130_fd_sc_hd__tapvpwrvgnd_1
XPHY_EDGE_ROW_87_Left_207 VGND VGND VPWR VPWR sky130_fd_sc_hd__decap_3
XFILLER_78_71 VGND VGND VPWR VPWR sky130_fd_sc_hd__decap_3
XFILLER_110_235 VGND VGND VPWR VPWR sky130_fd_sc_hd__decap_3
XFILLER_77_650 VGND VGND VPWR VPWR sky130_fd_sc_hd__decap_3
XFILLER_110_268 VGND VGND VPWR VPWR sky130_fd_sc_hd__decap_3
XFILLER_37_503 VGND VGND VPWR VPWR sky130_fd_sc_hd__fill_1
XFILLER_76_160 VGND VGND VPWR VPWR sky130_fd_sc_hd__decap_3
XFILLER_83_119 VGND VGND VPWR VPWR sky130_fd_sc_hd__decap_3
XFILLER_49_396 VGND VGND VPWR VPWR sky130_fd_sc_hd__decap_3
XFILLER_77_694 VGND VGND VPWR VPWR sky130_fd_sc_hd__decap_3
XFILLER_92_631 VGND VGND VPWR VPWR sky130_fd_sc_hd__decap_3
XFILLER_94_81 VGND VGND VPWR VPWR sky130_fd_sc_hd__decap_3
XTAP_TAPCELL_ROW_69_1123 VGND VPWR sky130_fd_sc_hd__tapvpwrvgnd_1
XFILLER_25_709 VGND VGND VPWR VPWR sky130_fd_sc_hd__decap_3
XFILLER_91_130 VGND VGND VPWR VPWR sky130_fd_sc_hd__decap_3
XFILLER_91_163 VGND VGND VPWR VPWR sky130_fd_sc_hd__decap_3
XFILLER_92_675 VGND VGND VPWR VPWR sky130_fd_sc_hd__decap_3
XFILLER_17_271 VGND VGND VPWR VPWR sky130_fd_sc_hd__fill_2
XFILLER_91_196 VGND VGND VPWR VPWR sky130_fd_sc_hd__decap_3
X_4941_ _4811_/C _4936_/Y _4940_/Y VGND VGND VPWR VPWR _5657_/C sky130_fd_sc_hd__a21o_2
X_4872_ _4872_/A _4872_/B VGND VGND VPWR VPWR _4872_/X sky130_fd_sc_hd__and2_2
XPHY_EDGE_ROW_96_Left_216 VGND VGND VPWR VPWR sky130_fd_sc_hd__decap_3
XFILLER_32_274 VGND VGND VPWR VPWR sky130_fd_sc_hd__decap_3
X_6611_ _6650_/A VGND VGND VPWR VPWR _6611_/Y sky130_fd_sc_hd__inv_2
X_3823_ _6947_/Q _3913_/B1 _3912_/B1 _6959_/Q VGND VGND VPWR VPWR _3823_/X sky130_fd_sc_hd__a22o_2
XTAP_TAPCELL_ROW_15_450 VGND VPWR sky130_fd_sc_hd__tapvpwrvgnd_1
XFILLER_20_436 VGND VGND VPWR VPWR sky130_fd_sc_hd__fill_1
XFILLER_20_458 VGND VGND VPWR VPWR sky130_fd_sc_hd__decap_3
XFILLER_32_296 VGND VGND VPWR VPWR sky130_fd_sc_hd__decap_3
XTAP_TAPCELL_ROW_43_792 VGND VPWR sky130_fd_sc_hd__tapvpwrvgnd_1
X_6542_ _6544_/A VGND VGND VPWR VPWR _6542_/Y sky130_fd_sc_hd__inv_2
X_3754_ _3754_/A1 _4799_/A _3753_/X VGND VGND VPWR VPWR _7397_/D sky130_fd_sc_hd__o21a_2
XFILLER_118_335 VGND VGND VPWR VPWR sky130_fd_sc_hd__decap_3
X_6473_ _6544_/A VGND VGND VPWR VPWR _6473_/Y sky130_fd_sc_hd__inv_2
XFILLER_114_530 VGND VGND VPWR VPWR sky130_fd_sc_hd__fill_2
XFILLER_58_19 VGND VGND VPWR VPWR sky130_fd_sc_hd__fill_1
XFILLER_99_263 VGND VGND VPWR VPWR sky130_fd_sc_hd__decap_3
XFILLER_114_585 VGND VGND VPWR VPWR sky130_fd_sc_hd__decap_3
XFILLER_59_105 VGND VGND VPWR VPWR sky130_fd_sc_hd__decap_3
XFILLER_59_116 VGND VGND VPWR VPWR sky130_fd_sc_hd__decap_3
XFILLER_87_425 VGND VGND VPWR VPWR sky130_fd_sc_hd__decap_3
XFILLER_87_436 VGND VGND VPWR VPWR sky130_fd_sc_hd__decap_3
X_5286_ _5286_/A0 _5139_/X _5292_/S VGND VGND VPWR VPWR _7186_/D sky130_fd_sc_hd__mux2_2
X_4306_ _7288_/Q _4335_/A2 _4351_/A2 _7096_/Q VGND VGND VPWR VPWR _4311_/A sky130_fd_sc_hd__a22o_2
XFILLER_114_14 VGND VGND VPWR VPWR sky130_fd_sc_hd__decap_3
XFILLER_59_149 VGND VGND VPWR VPWR sky130_fd_sc_hd__decap_3
XFILLER_87_458 VGND VGND VPWR VPWR sky130_fd_sc_hd__decap_3
X_7025_ _7342_/CLK _7025_/D _6305_/Y VGND VGND VPWR VPWR _7025_/Q sky130_fd_sc_hd__dfrtp_2
X_4237_ _7259_/Q _4601_/S _4236_/X VGND VGND VPWR VPWR _4237_/X sky130_fd_sc_hd__a21o_2
XFILLER_101_279 VGND VGND VPWR VPWR sky130_fd_sc_hd__fill_1
XFILLER_114_47 VGND VGND VPWR VPWR sky130_fd_sc_hd__decap_3
XFILLER_28_514 VGND VGND VPWR VPWR sky130_fd_sc_hd__fill_2
XFILLER_68_672 VGND VGND VPWR VPWR sky130_fd_sc_hd__decap_3
XFILLER_28_525 VGND VGND VPWR VPWR sky130_fd_sc_hd__decap_3
XFILLER_28_536 VGND VGND VPWR VPWR sky130_fd_sc_hd__fill_2
XFILLER_55_333 VGND VGND VPWR VPWR sky130_fd_sc_hd__decap_3
XFILLER_74_29 VGND VGND VPWR VPWR sky130_fd_sc_hd__fill_2
XFILLER_83_620 VGND VGND VPWR VPWR sky130_fd_sc_hd__decap_3
X_4168_ _7046_/Q _4269_/B1 _4272_/B _7361_/Q _4167_/X VGND VGND VPWR VPWR _4168_/X
+ sky130_fd_sc_hd__a221o_2
XFILLER_82_130 VGND VGND VPWR VPWR sky130_fd_sc_hd__decap_3
XFILLER_82_141 VGND VGND VPWR VPWR sky130_fd_sc_hd__decap_3
XFILLER_83_653 VGND VGND VPWR VPWR sky130_fd_sc_hd__decap_3
X_4099_ _7301_/Q _4233_/B1 _4421_/B1 _7173_/Q _4098_/X VGND VGND VPWR VPWR _4099_/X
+ sky130_fd_sc_hd__a221o_2
XFILLER_43_528 VGND VGND VPWR VPWR sky130_fd_sc_hd__decap_3
XFILLER_70_336 VGND VGND VPWR VPWR sky130_fd_sc_hd__decap_3
XFILLER_82_174 VGND VGND VPWR VPWR sky130_fd_sc_hd__decap_3
XFILLER_83_697 VGND VGND VPWR VPWR sky130_fd_sc_hd__decap_3
XFILLER_23_11 VGND VGND VPWR VPWR sky130_fd_sc_hd__fill_1
XFILLER_51_561 VGND VGND VPWR VPWR sky130_fd_sc_hd__decap_3
X_6809_ clkload9/A _6809_/D VGND VGND VPWR VPWR _6809_/Q sky130_fd_sc_hd__dfxtp_2
XFILLER_3_613 VGND VGND VPWR VPWR sky130_fd_sc_hd__decap_3
XFILLER_3_635 VGND VGND VPWR VPWR sky130_fd_sc_hd__decap_3
XFILLER_117_390 VGND VGND VPWR VPWR sky130_fd_sc_hd__fill_2
XFILLER_3_668 VGND VGND VPWR VPWR sky130_fd_sc_hd__decap_3
XFILLER_3_679 VGND VGND VPWR VPWR sky130_fd_sc_hd__decap_3
XFILLER_2_178 VGND VGND VPWR VPWR sky130_fd_sc_hd__fill_2
XFILLER_59_650 VGND VGND VPWR VPWR sky130_fd_sc_hd__decap_3
XFILLER_19_503 VGND VGND VPWR VPWR sky130_fd_sc_hd__fill_1
XFILLER_65_108 VGND VGND VPWR VPWR sky130_fd_sc_hd__decap_3
XFILLER_65_119 VGND VGND VPWR VPWR sky130_fd_sc_hd__decap_3
XFILLER_59_694 VGND VGND VPWR VPWR sky130_fd_sc_hd__decap_3
XFILLER_74_642 VGND VGND VPWR VPWR sky130_fd_sc_hd__fill_2
XFILLER_86_480 VGND VGND VPWR VPWR sky130_fd_sc_hd__decap_3
XFILLER_100_290 VGND VGND VPWR VPWR sky130_fd_sc_hd__decap_3
XFILLER_74_675 VGND VGND VPWR VPWR sky130_fd_sc_hd__decap_3
XFILLER_104_91 VGND VGND VPWR VPWR sky130_fd_sc_hd__decap_3
XFILLER_34_539 VGND VGND VPWR VPWR sky130_fd_sc_hd__decap_3
XFILLER_27_591 VGND VGND VPWR VPWR sky130_fd_sc_hd__decap_3
XFILLER_14_274 VGND VGND VPWR VPWR sky130_fd_sc_hd__decap_3
XFILLER_30_701 VGND VGND VPWR VPWR sky130_fd_sc_hd__decap_3
XFILLER_42_583 VGND VGND VPWR VPWR sky130_fd_sc_hd__decap_3
XTAP_TAPCELL_ROW_64_1064 VGND VPWR sky130_fd_sc_hd__tapvpwrvgnd_1
XTAP_TAPCELL_ROW_64_1053 VGND VPWR sky130_fd_sc_hd__tapvpwrvgnd_1
XFILLER_42_594 VGND VGND VPWR VPWR sky130_fd_sc_hd__decap_3
XFILLER_80_50 VGND VGND VPWR VPWR sky130_fd_sc_hd__fill_1
XFILLER_80_61 VGND VGND VPWR VPWR sky130_fd_sc_hd__decap_3
XTAP_TAPCELL_ROW_40_762 VGND VPWR sky130_fd_sc_hd__tapvpwrvgnd_1
XFILLER_80_94 VGND VGND VPWR VPWR sky130_fd_sc_hd__decap_3
XTAP_TAPCELL_ROW_116_1706 VGND VPWR sky130_fd_sc_hd__tapvpwrvgnd_1
XFILLER_10_491 VGND VGND VPWR VPWR sky130_fd_sc_hd__decap_3
Xhold908 _6920_/Q VGND VGND VPWR VPWR _6920_/D sky130_fd_sc_hd__dlygate4sd3_1
Xhold919 _6911_/Q VGND VGND VPWR VPWR _6911_/D sky130_fd_sc_hd__dlygate4sd3_1
XFILLER_89_70 VGND VGND VPWR VPWR sky130_fd_sc_hd__decap_3
X_3470_ _3468_/X _3424_/S _4537_/C _4537_/B VGND VGND VPWR VPWR _3545_/B sky130_fd_sc_hd__o2bb2a_2
XFILLER_111_511 VGND VGND VPWR VPWR sky130_fd_sc_hd__decap_3
XFILLER_36_3 VGND VGND VPWR VPWR sky130_fd_sc_hd__fill_2
XFILLER_96_200 VGND VGND VPWR VPWR sky130_fd_sc_hd__decap_3
XFILLER_97_712 VGND VGND VPWR VPWR sky130_fd_sc_hd__fill_2
X_5140_ _5140_/A0 _5139_/X _5142_/S VGND VGND VPWR VPWR _7250_/D sky130_fd_sc_hd__mux2_2
XTAP_TAPCELL_ROW_75_1193 VGND VPWR sky130_fd_sc_hd__tapvpwrvgnd_1
XFILLER_111_555 VGND VGND VPWR VPWR sky130_fd_sc_hd__decap_3
XFILLER_2_690 VGND VGND VPWR VPWR sky130_fd_sc_hd__decap_3
XFILLER_69_469 VGND VGND VPWR VPWR sky130_fd_sc_hd__decap_3
X_5071_ _5071_/A _5071_/B VGND VGND VPWR VPWR _5072_/C sky130_fd_sc_hd__nand2_2
XFILLER_111_588 VGND VGND VPWR VPWR sky130_fd_sc_hd__decap_3
XFILLER_96_266 VGND VGND VPWR VPWR sky130_fd_sc_hd__decap_3
XFILLER_37_322 VGND VGND VPWR VPWR sky130_fd_sc_hd__decap_3
XFILLER_65_620 VGND VGND VPWR VPWR sky130_fd_sc_hd__decap_3
XFILLER_77_491 VGND VGND VPWR VPWR sky130_fd_sc_hd__decap_3
XFILLER_37_355 VGND VGND VPWR VPWR sky130_fd_sc_hd__decap_3
XFILLER_64_141 VGND VGND VPWR VPWR sky130_fd_sc_hd__decap_3
XFILLER_65_653 VGND VGND VPWR VPWR sky130_fd_sc_hd__decap_3
XFILLER_92_450 VGND VGND VPWR VPWR sky130_fd_sc_hd__decap_3
XTAP_TAPCELL_ROW_48_862 VGND VPWR sky130_fd_sc_hd__tapvpwrvgnd_1
XFILLER_18_580 VGND VGND VPWR VPWR sky130_fd_sc_hd__decap_3
XFILLER_64_174 VGND VGND VPWR VPWR sky130_fd_sc_hd__decap_3
XFILLER_65_697 VGND VGND VPWR VPWR sky130_fd_sc_hd__decap_3
XFILLER_80_612 VGND VGND VPWR VPWR sky130_fd_sc_hd__decap_3
XFILLER_92_483 VGND VGND VPWR VPWR sky130_fd_sc_hd__decap_3
XFILLER_52_336 VGND VGND VPWR VPWR sky130_fd_sc_hd__decap_3
XFILLER_52_358 VGND VGND VPWR VPWR sky130_fd_sc_hd__fill_1
XFILLER_80_645 VGND VGND VPWR VPWR sky130_fd_sc_hd__decap_3
XFILLER_80_678 VGND VGND VPWR VPWR sky130_fd_sc_hd__decap_3
X_4924_ _4920_/A _4922_/X _4923_/Y VGND VGND VPWR VPWR _4924_/X sky130_fd_sc_hd__a21o_2
XFILLER_100_27 VGND VGND VPWR VPWR sky130_fd_sc_hd__fill_1
XFILLER_21_712 VGND VGND VPWR VPWR sky130_fd_sc_hd__fill_2
XFILLER_100_38 VGND VGND VPWR VPWR sky130_fd_sc_hd__decap_3
XFILLER_33_594 VGND VGND VPWR VPWR sky130_fd_sc_hd__decap_3
XFILLER_60_380 VGND VGND VPWR VPWR sky130_fd_sc_hd__decap_3
X_4855_ _4855_/A _4855_/B _4854_/X VGND VGND VPWR VPWR _5655_/D sky130_fd_sc_hd__or3b_4
XFILLER_119_600 VGND VGND VPWR VPWR sky130_fd_sc_hd__decap_3
X_4786_ _4795_/A _4795_/B _4648_/A VGND VGND VPWR VPWR _4787_/B sky130_fd_sc_hd__a21o_2
X_3806_ _6966_/Q _3912_/A2 _3913_/A2 _6954_/Q _3805_/X VGND VGND VPWR VPWR _3806_/X
+ sky130_fd_sc_hd__a221o_2
XFILLER_20_277 VGND VGND VPWR VPWR sky130_fd_sc_hd__decap_3
XFILLER_20_288 VGND VGND VPWR VPWR sky130_fd_sc_hd__decap_3
X_6525_ _6652_/A VGND VGND VPWR VPWR _6525_/Y sky130_fd_sc_hd__inv_2
X_3737_ _6752_/Q _3886_/A2 _3887_/B1 _6746_/Q VGND VGND VPWR VPWR _3737_/X sky130_fd_sc_hd__a22o_2
XFILLER_109_36 VGND VGND VPWR VPWR sky130_fd_sc_hd__decap_3
XFILLER_119_666 VGND VGND VPWR VPWR sky130_fd_sc_hd__decap_3
XFILLER_107_9 VGND VGND VPWR VPWR sky130_fd_sc_hd__decap_3
XFILLER_109_69 VGND VGND VPWR VPWR sky130_fd_sc_hd__decap_3
XFILLER_119_699 VGND VGND VPWR VPWR sky130_fd_sc_hd__fill_1
X_6456_ _6648_/A VGND VGND VPWR VPWR _6456_/Y sky130_fd_sc_hd__inv_2
X_3668_ _6943_/Q _3760_/A2 _3767_/B1 _6895_/Q VGND VGND VPWR VPWR _3668_/X sky130_fd_sc_hd__a22o_2
XFILLER_88_701 VGND VGND VPWR VPWR sky130_fd_sc_hd__decap_3
X_6387_ _6610_/A VGND VGND VPWR VPWR _6387_/Y sky130_fd_sc_hd__inv_2
X_5407_ _5407_/A0 _5061_/X _5427_/S VGND VGND VPWR VPWR _7130_/D sky130_fd_sc_hd__mux2_2
X_3599_ _3599_/A _3600_/A VGND VGND VPWR VPWR _4614_/C sky130_fd_sc_hd__nor2_2
XFILLER_102_522 VGND VGND VPWR VPWR sky130_fd_sc_hd__decap_3
XFILLER_87_211 VGND VGND VPWR VPWR sky130_fd_sc_hd__decap_3
X_5338_ _5338_/A0 _5061_/X _5340_/S VGND VGND VPWR VPWR _7162_/D sky130_fd_sc_hd__mux2_2
XFILLER_102_533 VGND VGND VPWR VPWR sky130_fd_sc_hd__decap_3
XFILLER_47_108 VGND VGND VPWR VPWR sky130_fd_sc_hd__decap_3
XFILLER_85_28 VGND VGND VPWR VPWR sky130_fd_sc_hd__fill_2
XFILLER_87_255 VGND VGND VPWR VPWR sky130_fd_sc_hd__decap_3
X_7008_ _7373_/CLK _7008_/D _6288_/Y VGND VGND VPWR VPWR _7008_/Q sky130_fd_sc_hd__dfrtp_2
XFILLER_56_631 VGND VGND VPWR VPWR sky130_fd_sc_hd__decap_3
XFILLER_68_480 VGND VGND VPWR VPWR sky130_fd_sc_hd__fill_1
XFILLER_28_344 VGND VGND VPWR VPWR sky130_fd_sc_hd__decap_3
XFILLER_55_130 VGND VGND VPWR VPWR sky130_fd_sc_hd__decap_3
XFILLER_56_675 VGND VGND VPWR VPWR sky130_fd_sc_hd__decap_3
XFILLER_71_601 VGND VGND VPWR VPWR sky130_fd_sc_hd__decap_3
XFILLER_18_88 VGND VGND VPWR VPWR sky130_fd_sc_hd__decap_3
XFILLER_28_377 VGND VGND VPWR VPWR sky130_fd_sc_hd__decap_3
XFILLER_43_314 VGND VGND VPWR VPWR sky130_fd_sc_hd__fill_2
XFILLER_70_100 VGND VGND VPWR VPWR sky130_fd_sc_hd__decap_3
XFILLER_71_623 VGND VGND VPWR VPWR sky130_fd_sc_hd__decap_3
XFILLER_83_494 VGND VGND VPWR VPWR sky130_fd_sc_hd__decap_3
XFILLER_34_21 VGND VGND VPWR VPWR sky130_fd_sc_hd__decap_3
XFILLER_70_133 VGND VGND VPWR VPWR sky130_fd_sc_hd__decap_3
XFILLER_71_656 VGND VGND VPWR VPWR sky130_fd_sc_hd__decap_3
XFILLER_12_701 VGND VGND VPWR VPWR sky130_fd_sc_hd__decap_3
XTAP_TAPCELL_ROW_26_589 VGND VPWR sky130_fd_sc_hd__tapvpwrvgnd_1
XTAP_TAPCELL_ROW_26_578 VGND VPWR sky130_fd_sc_hd__tapvpwrvgnd_1
XTAP_TAPCELL_ROW_100_1507 VGND VPWR sky130_fd_sc_hd__tapvpwrvgnd_1
XFILLER_24_583 VGND VGND VPWR VPWR sky130_fd_sc_hd__decap_3
XFILLER_11_233 VGND VGND VPWR VPWR sky130_fd_sc_hd__decap_3
XFILLER_50_42 VGND VGND VPWR VPWR sky130_fd_sc_hd__fill_2
XFILLER_109_143 VGND VGND VPWR VPWR sky130_fd_sc_hd__decap_3
XFILLER_109_187 VGND VGND VPWR VPWR sky130_fd_sc_hd__fill_2
XFILLER_3_487 VGND VGND VPWR VPWR sky130_fd_sc_hd__decap_3
XFILLER_79_712 VGND VGND VPWR VPWR sky130_fd_sc_hd__fill_2
XFILLER_78_233 VGND VGND VPWR VPWR sky130_fd_sc_hd__fill_2
XTAP_TAPCELL_ROW_111_1647 VGND VPWR sky130_fd_sc_hd__tapvpwrvgnd_1
XFILLER_66_406 VGND VGND VPWR VPWR sky130_fd_sc_hd__decap_3
XFILLER_94_704 VGND VGND VPWR VPWR sky130_fd_sc_hd__decap_3
XFILLER_115_90 VGND VGND VPWR VPWR sky130_fd_sc_hd__decap_3
XFILLER_19_322 VGND VGND VPWR VPWR sky130_fd_sc_hd__fill_1
XFILLER_47_620 VGND VGND VPWR VPWR sky130_fd_sc_hd__decap_3
XFILLER_93_225 VGND VGND VPWR VPWR sky130_fd_sc_hd__decap_3
XFILLER_47_653 VGND VGND VPWR VPWR sky130_fd_sc_hd__decap_3
XFILLER_46_174 VGND VGND VPWR VPWR sky130_fd_sc_hd__decap_3
XFILLER_47_697 VGND VGND VPWR VPWR sky130_fd_sc_hd__decap_3
XFILLER_62_623 VGND VGND VPWR VPWR sky130_fd_sc_hd__decap_3
XFILLER_74_472 VGND VGND VPWR VPWR sky130_fd_sc_hd__decap_3
XTAP_TAPCELL_ROW_45_821 VGND VPWR sky130_fd_sc_hd__tapvpwrvgnd_1
XFILLER_34_336 VGND VGND VPWR VPWR sky130_fd_sc_hd__decap_3
XFILLER_34_347 VGND VGND VPWR VPWR sky130_fd_sc_hd__fill_1
XFILLER_61_122 VGND VGND VPWR VPWR sky130_fd_sc_hd__decap_3
XFILLER_62_645 VGND VGND VPWR VPWR sky130_fd_sc_hd__decap_3
XFILLER_15_550 VGND VGND VPWR VPWR sky130_fd_sc_hd__decap_3
XFILLER_15_572 VGND VGND VPWR VPWR sky130_fd_sc_hd__decap_3
XFILLER_61_155 VGND VGND VPWR VPWR sky130_fd_sc_hd__decap_3
XFILLER_62_678 VGND VGND VPWR VPWR sky130_fd_sc_hd__decap_3
XFILLER_30_531 VGND VGND VPWR VPWR sky130_fd_sc_hd__fill_1
XFILLER_42_391 VGND VGND VPWR VPWR sky130_fd_sc_hd__decap_3
XFILLER_61_188 VGND VGND VPWR VPWR sky130_fd_sc_hd__decap_3
XFILLER_91_71 VGND VGND VPWR VPWR sky130_fd_sc_hd__decap_3
XFILLER_30_553 VGND VGND VPWR VPWR sky130_fd_sc_hd__decap_3
X_4640_ _4938_/B _4918_/A VGND VGND VPWR VPWR _4640_/Y sky130_fd_sc_hd__nor2_2
X_6310_ _6593_/A VGND VGND VPWR VPWR _6310_/Y sky130_fd_sc_hd__inv_2
X_4571_ _7295_/Q _4577_/B VGND VGND VPWR VPWR _7295_/D sky130_fd_sc_hd__and2_2
XTAP_TAPCELL_ROW_77_1222 VGND VPWR sky130_fd_sc_hd__tapvpwrvgnd_1
XFILLER_115_102 VGND VGND VPWR VPWR sky130_fd_sc_hd__fill_2
XFILLER_115_113 VGND VGND VPWR VPWR sky130_fd_sc_hd__fill_2
XFILLER_116_625 VGND VGND VPWR VPWR sky130_fd_sc_hd__decap_3
X_7290_ _7322_/CLK _7290_/D _6570_/Y VGND VGND VPWR VPWR _7290_/Q sky130_fd_sc_hd__dfrtp_2
Xhold705 _6919_/Q VGND VGND VPWR VPWR _6919_/D sky130_fd_sc_hd__dlygate4sd3_1
Xhold716 _6978_/Q VGND VGND VPWR VPWR _6978_/D sky130_fd_sc_hd__dlygate4sd3_1
Xhold727 _6810_/Q VGND VGND VPWR VPWR _6810_/D sky130_fd_sc_hd__dlygate4sd3_1
X_3522_ _5118_/C _4938_/A _3618_/C VGND VGND VPWR VPWR _5020_/A sky130_fd_sc_hd__nand3_2
XFILLER_116_669 VGND VGND VPWR VPWR sky130_fd_sc_hd__decap_3
Xhold738 _6889_/Q VGND VGND VPWR VPWR _6889_/D sky130_fd_sc_hd__dlygate4sd3_1
Xhold749 _6827_/Q VGND VGND VPWR VPWR _6827_/D sky130_fd_sc_hd__dlygate4sd3_1
X_3453_ _7218_/Q _4307_/A2 _4346_/B1 _7378_/Q VGND VGND VPWR VPWR _3453_/X sky130_fd_sc_hd__a22o_2
XFILLER_97_553 VGND VGND VPWR VPWR sky130_fd_sc_hd__decap_3
X_3384_ _7315_/Q _3987_/S _4528_/B _7283_/Q VGND VGND VPWR VPWR _3384_/X sky130_fd_sc_hd__a22o_2
XFILLER_69_266 VGND VGND VPWR VPWR sky130_fd_sc_hd__fill_1
XFILLER_84_203 VGND VGND VPWR VPWR sky130_fd_sc_hd__decap_3
XFILLER_97_564 VGND VGND VPWR VPWR sky130_fd_sc_hd__decap_3
XFILLER_38_631 VGND VGND VPWR VPWR sky130_fd_sc_hd__decap_3
XFILLER_69_299 VGND VGND VPWR VPWR sky130_fd_sc_hd__decap_3
XFILLER_84_236 VGND VGND VPWR VPWR sky130_fd_sc_hd__decap_3
X_5054_ _5054_/A VGND VGND VPWR VPWR _5054_/Y sky130_fd_sc_hd__inv_2
XFILLER_37_130 VGND VGND VPWR VPWR sky130_fd_sc_hd__fill_1
XFILLER_84_269 VGND VGND VPWR VPWR sky130_fd_sc_hd__decap_3
XFILLER_37_152 VGND VGND VPWR VPWR sky130_fd_sc_hd__fill_1
XFILLER_38_675 VGND VGND VPWR VPWR sky130_fd_sc_hd__decap_3
XFILLER_53_612 VGND VGND VPWR VPWR sky130_fd_sc_hd__decap_3
XFILLER_53_623 VGND VGND VPWR VPWR sky130_fd_sc_hd__decap_3
XFILLER_65_461 VGND VGND VPWR VPWR sky130_fd_sc_hd__decap_3
XTAP_TAPCELL_ROW_88_1362 VGND VPWR sky130_fd_sc_hd__tapvpwrvgnd_1
XFILLER_111_15 VGND VGND VPWR VPWR sky130_fd_sc_hd__decap_3
XFILLER_37_185 VGND VGND VPWR VPWR sky130_fd_sc_hd__decap_3
XFILLER_53_656 VGND VGND VPWR VPWR sky130_fd_sc_hd__decap_3
XFILLER_65_494 VGND VGND VPWR VPWR sky130_fd_sc_hd__decap_3
XFILLER_111_48 VGND VGND VPWR VPWR sky130_fd_sc_hd__decap_3
XFILLER_25_369 VGND VGND VPWR VPWR sky130_fd_sc_hd__decap_3
XFILLER_80_475 VGND VGND VPWR VPWR sky130_fd_sc_hd__fill_1
XFILLER_80_486 VGND VGND VPWR VPWR sky130_fd_sc_hd__decap_3
XFILLER_21_531 VGND VGND VPWR VPWR sky130_fd_sc_hd__decap_3
XFILLER_33_380 VGND VGND VPWR VPWR sky130_fd_sc_hd__fill_2
X_4907_ _4948_/A _4888_/B _4903_/X _4906_/X VGND VGND VPWR VPWR _4907_/Y sky130_fd_sc_hd__o31ai_4
XFILLER_21_564 VGND VGND VPWR VPWR sky130_fd_sc_hd__decap_3
XTAP_TAPCELL_ROW_23_548 VGND VPWR sky130_fd_sc_hd__tapvpwrvgnd_1
XFILLER_21_597 VGND VGND VPWR VPWR sky130_fd_sc_hd__decap_3
XFILLER_119_452 VGND VGND VPWR VPWR sky130_fd_sc_hd__decap_3
X_4769_ _4969_/B _4741_/X _4761_/Y _4768_/Y VGND VGND VPWR VPWR _5663_/A sky130_fd_sc_hd__a31o_2
XFILLER_106_113 VGND VGND VPWR VPWR sky130_fd_sc_hd__decap_3
XFILLER_107_647 VGND VGND VPWR VPWR sky130_fd_sc_hd__decap_3
XFILLER_119_474 VGND VGND VPWR VPWR sky130_fd_sc_hd__fill_2
X_6508_ _6639_/A VGND VGND VPWR VPWR _6508_/Y sky130_fd_sc_hd__inv_2
XTAP_TAPCELL_ROW_99_1491 VGND VPWR sky130_fd_sc_hd__tapvpwrvgnd_1
XFILLER_105_6 VGND VGND VPWR VPWR sky130_fd_sc_hd__decap_3
XFILLER_20_45 VGND VGND VPWR VPWR sky130_fd_sc_hd__decap_3
X_6439_ _6636_/A VGND VGND VPWR VPWR _6439_/Y sky130_fd_sc_hd__inv_2
XFILLER_0_402 VGND VGND VPWR VPWR sky130_fd_sc_hd__decap_3
XFILLER_0_435 VGND VGND VPWR VPWR sky130_fd_sc_hd__decap_3
XFILLER_115_691 VGND VGND VPWR VPWR sky130_fd_sc_hd__decap_3
XFILLER_88_553 VGND VGND VPWR VPWR sky130_fd_sc_hd__fill_2
XFILLER_96_49 VGND VGND VPWR VPWR sky130_fd_sc_hd__fill_2
XFILLER_102_363 VGND VGND VPWR VPWR sky130_fd_sc_hd__fill_1
XFILLER_76_704 VGND VGND VPWR VPWR sky130_fd_sc_hd__decap_3
XFILLER_88_575 VGND VGND VPWR VPWR sky130_fd_sc_hd__decap_3
XFILLER_29_620 VGND VGND VPWR VPWR sky130_fd_sc_hd__decap_3
XFILLER_75_225 VGND VGND VPWR VPWR sky130_fd_sc_hd__decap_3
XFILLER_28_141 VGND VGND VPWR VPWR sky130_fd_sc_hd__decap_3
XFILLER_29_653 VGND VGND VPWR VPWR sky130_fd_sc_hd__decap_3
XFILLER_75_258 VGND VGND VPWR VPWR sky130_fd_sc_hd__fill_1
XFILLER_28_174 VGND VGND VPWR VPWR sky130_fd_sc_hd__decap_3
XFILLER_29_697 VGND VGND VPWR VPWR sky130_fd_sc_hd__decap_3
XFILLER_44_601 VGND VGND VPWR VPWR sky130_fd_sc_hd__decap_3
XFILLER_45_31 VGND VGND VPWR VPWR sky130_fd_sc_hd__fill_2
Xplace409 _5159_/S VGND VGND VPWR VPWR _5028_/S sky130_fd_sc_hd__buf_2
XTAP_TAPCELL_ROW_3_295 VGND VPWR sky130_fd_sc_hd__tapvpwrvgnd_1
XFILLER_16_347 VGND VGND VPWR VPWR sky130_fd_sc_hd__decap_3
XFILLER_44_634 VGND VGND VPWR VPWR sky130_fd_sc_hd__decap_3
XFILLER_44_645 VGND VGND VPWR VPWR sky130_fd_sc_hd__decap_3
XFILLER_45_42 VGND VGND VPWR VPWR sky130_fd_sc_hd__decap_3
XFILLER_56_494 VGND VGND VPWR VPWR sky130_fd_sc_hd__fill_2
XFILLER_71_420 VGND VGND VPWR VPWR sky130_fd_sc_hd__decap_3
XFILLER_43_166 VGND VGND VPWR VPWR sky130_fd_sc_hd__fill_2
XFILLER_44_678 VGND VGND VPWR VPWR sky130_fd_sc_hd__decap_3
XFILLER_71_464 VGND VGND VPWR VPWR sky130_fd_sc_hd__fill_1
XFILLER_24_380 VGND VGND VPWR VPWR sky130_fd_sc_hd__decap_3
XFILLER_43_199 VGND VGND VPWR VPWR sky130_fd_sc_hd__decap_3
XTAP_TAPCELL_ROW_61_1023 VGND VPWR sky130_fd_sc_hd__tapvpwrvgnd_1
XFILLER_101_81 VGND VGND VPWR VPWR sky130_fd_sc_hd__decap_3
XFILLER_61_52 VGND VGND VPWR VPWR sky130_fd_sc_hd__decap_3
XFILLER_12_575 VGND VGND VPWR VPWR sky130_fd_sc_hd__decap_3
XFILLER_61_74 VGND VGND VPWR VPWR sky130_fd_sc_hd__decap_3
XFILLER_8_557 VGND VGND VPWR VPWR sky130_fd_sc_hd__decap_3
XANTENNA_7 _3562_/B VGND VGND VPWR VPWR sky130_fd_sc_hd__diode_2
XFILLER_113_606 VGND VGND VPWR VPWR sky130_fd_sc_hd__decap_3
XFILLER_113_617 VGND VGND VPWR VPWR sky130_fd_sc_hd__decap_3
XFILLER_3_240 VGND VGND VPWR VPWR sky130_fd_sc_hd__decap_3
XFILLER_3_273 VGND VGND VPWR VPWR sky130_fd_sc_hd__decap_3
XFILLER_3_284 VGND VGND VPWR VPWR sky130_fd_sc_hd__decap_3
XTAP_TAPCELL_ROW_72_1152 VGND VPWR sky130_fd_sc_hd__tapvpwrvgnd_1
XFILLER_105_190 VGND VGND VPWR VPWR sky130_fd_sc_hd__decap_3
XFILLER_79_564 VGND VGND VPWR VPWR sky130_fd_sc_hd__fill_1
XTAP_TAPCELL_ROW_72_1163 VGND VPWR sky130_fd_sc_hd__tapvpwrvgnd_1
XFILLER_66_203 VGND VGND VPWR VPWR sky130_fd_sc_hd__decap_3
XFILLER_66_236 VGND VGND VPWR VPWR sky130_fd_sc_hd__decap_3
XFILLER_86_82 VGND VGND VPWR VPWR sky130_fd_sc_hd__fill_2
XFILLER_19_141 VGND VGND VPWR VPWR sky130_fd_sc_hd__decap_3
XFILLER_66_269 VGND VGND VPWR VPWR sky130_fd_sc_hd__fill_1
XFILLER_82_707 VGND VGND VPWR VPWR sky130_fd_sc_hd__decap_3
XFILLER_35_612 VGND VGND VPWR VPWR sky130_fd_sc_hd__decap_3
XFILLER_35_623 VGND VGND VPWR VPWR sky130_fd_sc_hd__decap_3
XFILLER_35_656 VGND VGND VPWR VPWR sky130_fd_sc_hd__decap_3
XFILLER_62_442 VGND VGND VPWR VPWR sky130_fd_sc_hd__decap_3
XFILLER_22_306 VGND VGND VPWR VPWR sky130_fd_sc_hd__fill_2
XFILLER_34_144 VGND VGND VPWR VPWR sky130_fd_sc_hd__fill_1
X_6790_ clkload9/A _6790_/D VGND VGND VPWR VPWR _6790_/Q sky130_fd_sc_hd__dfxtp_2
XFILLER_50_626 VGND VGND VPWR VPWR sky130_fd_sc_hd__decap_3
XFILLER_50_648 VGND VGND VPWR VPWR sky130_fd_sc_hd__decap_3
XFILLER_62_486 VGND VGND VPWR VPWR sky130_fd_sc_hd__fill_2
XFILLER_62_497 VGND VGND VPWR VPWR sky130_fd_sc_hd__fill_1
XTAP_TAPCELL_ROW_83_1292 VGND VPWR sky130_fd_sc_hd__tapvpwrvgnd_1
XTAP_TAPCELL_ROW_20_507 VGND VPWR sky130_fd_sc_hd__tapvpwrvgnd_1
XFILLER_30_394 VGND VGND VPWR VPWR sky130_fd_sc_hd__decap_3
X_4623_ _4330_/B _4622_/X _5057_/B VGND VGND VPWR VPWR _4624_/A sky130_fd_sc_hd__o21ba_2
X_7342_ _7342_/CLK _7342_/D _6622_/Y VGND VGND VPWR VPWR _7342_/Q sky130_fd_sc_hd__dfrtp_2
X_4554_ _4554_/A _4563_/B VGND VGND VPWR VPWR _7303_/D sky130_fd_sc_hd__and2_2
XFILLER_116_444 VGND VGND VPWR VPWR sky130_fd_sc_hd__fill_2
X_7273_ _7402_/CLK _7273_/D _6553_/Y VGND VGND VPWR VPWR _7273_/Q sky130_fd_sc_hd__dfrtp_2
X_3505_ _3505_/A _3505_/B VGND VGND VPWR VPWR _3505_/X sky130_fd_sc_hd__or2_4
XFILLER_104_628 VGND VGND VPWR VPWR sky130_fd_sc_hd__decap_3
XFILLER_116_477 VGND VGND VPWR VPWR sky130_fd_sc_hd__fill_2
XFILLER_89_328 VGND VGND VPWR VPWR sky130_fd_sc_hd__fill_1
XFILLER_103_116 VGND VGND VPWR VPWR sky130_fd_sc_hd__decap_3
XFILLER_103_149 VGND VGND VPWR VPWR sky130_fd_sc_hd__decap_3
XFILLER_106_26 VGND VGND VPWR VPWR sky130_fd_sc_hd__fill_2
XFILLER_112_672 VGND VGND VPWR VPWR sky130_fd_sc_hd__decap_3
XFILLER_58_704 VGND VGND VPWR VPWR sky130_fd_sc_hd__decap_3
XFILLER_111_182 VGND VGND VPWR VPWR sky130_fd_sc_hd__decap_3
XFILLER_57_203 VGND VGND VPWR VPWR sky130_fd_sc_hd__decap_3
XFILLER_57_225 VGND VGND VPWR VPWR sky130_fd_sc_hd__decap_3
Xhold1202 _7149_/Q VGND VGND VPWR VPWR _5367_/A0 sky130_fd_sc_hd__dlygate4sd3_1
Xhold1213 _7137_/Q VGND VGND VPWR VPWR _5392_/A0 sky130_fd_sc_hd__dlygate4sd3_1
Xhold1224 _7386_/Q VGND VGND VPWR VPWR _3860_/A0 sky130_fd_sc_hd__dlygate4sd3_1
X_5106_ _6985_/Q _5068_/C _5581_/S VGND VGND VPWR VPWR _5106_/X sky130_fd_sc_hd__o21a_2
Xhold1235 _7218_/Q VGND VGND VPWR VPWR _5221_/A sky130_fd_sc_hd__dlygate4sd3_1
Xhold1246 _7223_/Q VGND VGND VPWR VPWR _5211_/A sky130_fd_sc_hd__dlygate4sd3_1
Xhold1257 _7177_/Q VGND VGND VPWR VPWR _5306_/A0 sky130_fd_sc_hd__dlygate4sd3_1
X_5037_ _6988_/Q _5045_/B VGND VGND VPWR VPWR _5038_/B sky130_fd_sc_hd__nand2_2
XFILLER_26_601 VGND VGND VPWR VPWR sky130_fd_sc_hd__decap_3
XFILLER_72_206 VGND VGND VPWR VPWR sky130_fd_sc_hd__decap_3
XFILLER_72_228 VGND VGND VPWR VPWR sky130_fd_sc_hd__decap_3
Xhold1268 _6693_/Q VGND VGND VPWR VPWR _5686_/A1 sky130_fd_sc_hd__dlygate4sd3_1
Xhold1279 _7377_/Q VGND VGND VPWR VPWR _3920_/A1 sky130_fd_sc_hd__dlygate4sd3_1
XTAP_TAPCELL_ROW_28_607 VGND VPWR sky130_fd_sc_hd__tapvpwrvgnd_1
XFILLER_25_111 VGND VGND VPWR VPWR sky130_fd_sc_hd__fill_1
XFILLER_25_122 VGND VGND VPWR VPWR sky130_fd_sc_hd__decap_3
XFILLER_26_634 VGND VGND VPWR VPWR sky130_fd_sc_hd__decap_3
XFILLER_26_645 VGND VGND VPWR VPWR sky130_fd_sc_hd__decap_3
XFILLER_53_442 VGND VGND VPWR VPWR sky130_fd_sc_hd__decap_3
XFILLER_65_291 VGND VGND VPWR VPWR sky130_fd_sc_hd__decap_3
XTAP_TAPCELL_ROW_0_254 VGND VPWR sky130_fd_sc_hd__tapvpwrvgnd_1
XTAP_TAPCELL_ROW_0_243 VGND VPWR sky130_fd_sc_hd__tapvpwrvgnd_1
XFILLER_26_678 VGND VGND VPWR VPWR sky130_fd_sc_hd__decap_3
XFILLER_41_615 VGND VGND VPWR VPWR sky130_fd_sc_hd__fill_1
XFILLER_53_475 VGND VGND VPWR VPWR sky130_fd_sc_hd__decap_3
XFILLER_13_328 VGND VGND VPWR VPWR sky130_fd_sc_hd__decap_3
XFILLER_25_199 VGND VGND VPWR VPWR sky130_fd_sc_hd__decap_3
XFILLER_41_626 VGND VGND VPWR VPWR sky130_fd_sc_hd__decap_3
X_6988_ _7396_/CLK _6988_/D _6268_/Y VGND VGND VPWR VPWR _6988_/Q sky130_fd_sc_hd__dfrtp_2
XFILLER_41_659 VGND VGND VPWR VPWR sky130_fd_sc_hd__decap_3
XFILLER_40_169 VGND VGND VPWR VPWR sky130_fd_sc_hd__decap_3
XFILLER_5_505 VGND VGND VPWR VPWR sky130_fd_sc_hd__decap_3
XFILLER_119_271 VGND VGND VPWR VPWR sky130_fd_sc_hd__fill_1
XFILLER_107_455 VGND VGND VPWR VPWR sky130_fd_sc_hd__decap_3
XFILLER_103_3 VGND VGND VPWR VPWR sky130_fd_sc_hd__decap_3
XFILLER_107_488 VGND VGND VPWR VPWR sky130_fd_sc_hd__decap_3
XFILLER_1_700 VGND VGND VPWR VPWR sky130_fd_sc_hd__decap_3
XTAP_TAPCELL_ROW_8_354 VGND VPWR sky130_fd_sc_hd__tapvpwrvgnd_1
XFILLER_0_243 VGND VGND VPWR VPWR sky130_fd_sc_hd__decap_3
XFILLER_103_650 VGND VGND VPWR VPWR sky130_fd_sc_hd__decap_3
XFILLER_76_501 VGND VGND VPWR VPWR sky130_fd_sc_hd__decap_3
XFILLER_88_361 VGND VGND VPWR VPWR sky130_fd_sc_hd__decap_3
XFILLER_0_287 VGND VGND VPWR VPWR sky130_fd_sc_hd__decap_3
XFILLER_102_171 VGND VGND VPWR VPWR sky130_fd_sc_hd__decap_3
XFILLER_103_694 VGND VGND VPWR VPWR sky130_fd_sc_hd__decap_3
XFILLER_48_225 VGND VGND VPWR VPWR sky130_fd_sc_hd__decap_3
XFILLER_88_383 VGND VGND VPWR VPWR sky130_fd_sc_hd__decap_3
XFILLER_64_707 VGND VGND VPWR VPWR sky130_fd_sc_hd__decap_3
XFILLER_29_472 VGND VGND VPWR VPWR sky130_fd_sc_hd__fill_2
XFILLER_56_52 VGND VGND VPWR VPWR sky130_fd_sc_hd__decap_3
XFILLER_56_74 VGND VGND VPWR VPWR sky130_fd_sc_hd__decap_3
XFILLER_76_589 VGND VGND VPWR VPWR sky130_fd_sc_hd__decap_3
XFILLER_91_526 VGND VGND VPWR VPWR sky130_fd_sc_hd__decap_3
XFILLER_16_111 VGND VGND VPWR VPWR sky130_fd_sc_hd__decap_3
XFILLER_17_623 VGND VGND VPWR VPWR sky130_fd_sc_hd__decap_3
XFILLER_17_656 VGND VGND VPWR VPWR sky130_fd_sc_hd__decap_3
XFILLER_56_96 VGND VGND VPWR VPWR sky130_fd_sc_hd__decap_3
XFILLER_91_559 VGND VGND VPWR VPWR sky130_fd_sc_hd__fill_1
XFILLER_16_155 VGND VGND VPWR VPWR sky130_fd_sc_hd__fill_2
XFILLER_32_604 VGND VGND VPWR VPWR sky130_fd_sc_hd__decap_3
XTAP_TAPCELL_ROW_106_1579 VGND VPWR sky130_fd_sc_hd__tapvpwrvgnd_1
XFILLER_112_80 VGND VGND VPWR VPWR sky130_fd_sc_hd__decap_3
XFILLER_31_125 VGND VGND VPWR VPWR sky130_fd_sc_hd__decap_3
XFILLER_32_637 VGND VGND VPWR VPWR sky130_fd_sc_hd__decap_3
XFILLER_32_648 VGND VGND VPWR VPWR sky130_fd_sc_hd__decap_3
XFILLER_44_486 VGND VGND VPWR VPWR sky130_fd_sc_hd__decap_3
XFILLER_72_51 VGND VGND VPWR VPWR sky130_fd_sc_hd__decap_3
XFILLER_31_169 VGND VGND VPWR VPWR sky130_fd_sc_hd__decap_3
XFILLER_40_681 VGND VGND VPWR VPWR sky130_fd_sc_hd__decap_3
XFILLER_8_321 VGND VGND VPWR VPWR sky130_fd_sc_hd__decap_3
XFILLER_68_6 VGND VGND VPWR VPWR sky130_fd_sc_hd__decap_3
Xoutput618 place202/X VGND VGND VPWR VPWR instruction_out[25] sky130_fd_sc_hd__clkdlybuf4s25_1
Xoutput607 _3525_/A VGND VGND VPWR VPWR instruction_out[13] sky130_fd_sc_hd__clkdlybuf4s25_1
XFILLER_4_560 VGND VGND VPWR VPWR sky130_fd_sc_hd__decap_3
Xoutput629 _5362_/C VGND VGND VPWR VPWR instruction_out[8] sky130_fd_sc_hd__clkdlybuf4s25_1
XFILLER_99_626 VGND VGND VPWR VPWR sky130_fd_sc_hd__decap_3
XFILLER_98_114 VGND VGND VPWR VPWR sky130_fd_sc_hd__decap_3
X_4270_ _7358_/Q _4272_/B VGND VGND VPWR VPWR _4270_/Y sky130_fd_sc_hd__nand2_2
XFILLER_99_659 VGND VGND VPWR VPWR sky130_fd_sc_hd__decap_3
XFILLER_101_609 VGND VGND VPWR VPWR sky130_fd_sc_hd__decap_3
XFILLER_86_309 VGND VGND VPWR VPWR sky130_fd_sc_hd__decap_3
XFILLER_100_119 VGND VGND VPWR VPWR sky130_fd_sc_hd__decap_3
XFILLER_39_214 VGND VGND VPWR VPWR sky130_fd_sc_hd__decap_3
XFILLER_39_225 VGND VGND VPWR VPWR sky130_fd_sc_hd__decap_3
XFILLER_79_372 VGND VGND VPWR VPWR sky130_fd_sc_hd__fill_2
XFILLER_79_383 VGND VGND VPWR VPWR sky130_fd_sc_hd__fill_1
XFILLER_39_258 VGND VGND VPWR VPWR sky130_fd_sc_hd__decap_3
XFILLER_67_545 VGND VGND VPWR VPWR sky130_fd_sc_hd__decap_3
XFILLER_54_206 VGND VGND VPWR VPWR sky130_fd_sc_hd__decap_3
XFILLER_82_504 VGND VGND VPWR VPWR sky130_fd_sc_hd__decap_3
XFILLER_94_375 VGND VGND VPWR VPWR sky130_fd_sc_hd__decap_3
X_6911_ clkload8/A _6911_/D VGND VGND VPWR VPWR _6911_/Q sky130_fd_sc_hd__dfxtp_2
XTAP_TAPCELL_ROW_85_1321 VGND VPWR sky130_fd_sc_hd__tapvpwrvgnd_1
XFILLER_23_615 VGND VGND VPWR VPWR sky130_fd_sc_hd__fill_1
X_6842_ clkload5/A _6842_/D VGND VGND VPWR VPWR _6842_/Q sky130_fd_sc_hd__dfxtp_2
XTAP_TAPCELL_ROW_53_919 VGND VPWR sky130_fd_sc_hd__tapvpwrvgnd_1
XFILLER_22_103 VGND VGND VPWR VPWR sky130_fd_sc_hd__decap_3
XFILLER_23_626 VGND VGND VPWR VPWR sky130_fd_sc_hd__decap_3
XFILLER_50_412 VGND VGND VPWR VPWR sky130_fd_sc_hd__decap_3
XFILLER_23_659 VGND VGND VPWR VPWR sky130_fd_sc_hd__decap_3
XFILLER_50_467 VGND VGND VPWR VPWR sky130_fd_sc_hd__fill_1
XFILLER_62_294 VGND VGND VPWR VPWR sky130_fd_sc_hd__fill_2
X_6773_ _6983_/CLK _6773_/D VGND VGND VPWR VPWR _6773_/Q sky130_fd_sc_hd__dfxtp_2
X_3985_ _7348_/Q _4526_/A0 _3987_/S VGND VGND VPWR VPWR _7348_/D sky130_fd_sc_hd__mux2_2
XFILLER_10_309 VGND VGND VPWR VPWR sky130_fd_sc_hd__decap_3
XFILLER_50_489 VGND VGND VPWR VPWR sky130_fd_sc_hd__decap_3
XTAP_TAPCELL_ROW_33_676 VGND VPWR sky130_fd_sc_hd__tapvpwrvgnd_1
XTAP_TAPCELL_ROW_33_665 VGND VPWR sky130_fd_sc_hd__tapvpwrvgnd_1
XFILLER_109_709 VGND VGND VPWR VPWR sky130_fd_sc_hd__decap_3
XFILLER_30_180 VGND VGND VPWR VPWR sky130_fd_sc_hd__decap_3
X_5655_ _5655_/A _5655_/B _5655_/C _5655_/D VGND VGND VPWR VPWR _5665_/B sky130_fd_sc_hd__nor4_2
X_4606_ _4606_/A _5633_/B VGND VGND VPWR VPWR _5092_/C sky130_fd_sc_hd__nor2_2
X_7325_ _7357_/CLK _7325_/D _6605_/Y VGND VGND VPWR VPWR _7325_/Q sky130_fd_sc_hd__dfrtp_2
X_5586_ _5586_/A1 _5595_/B _5118_/X VGND VGND VPWR VPWR _7035_/D sky130_fd_sc_hd__o21a_2
XTAP_TAPCELL_ROW_96_1461 VGND VPWR sky130_fd_sc_hd__tapvpwrvgnd_1
XPHY_EDGE_ROW_107_Left_227 VGND VGND VPWR VPWR sky130_fd_sc_hd__decap_3
XFILLER_117_14 VGND VGND VPWR VPWR sky130_fd_sc_hd__decap_3
XFILLER_2_519 VGND VGND VPWR VPWR sky130_fd_sc_hd__decap_3
XFILLER_89_103 VGND VGND VPWR VPWR sky130_fd_sc_hd__decap_3
X_4537_ _5118_/A _4537_/B _4537_/C VGND VGND VPWR VPWR _4595_/B sky130_fd_sc_hd__or3_2
XFILLER_104_447 VGND VGND VPWR VPWR sky130_fd_sc_hd__decap_3
XFILLER_117_47 VGND VGND VPWR VPWR sky130_fd_sc_hd__decap_3
XFILLER_117_69 VGND VGND VPWR VPWR sky130_fd_sc_hd__decap_3
XFILLER_89_125 VGND VGND VPWR VPWR sky130_fd_sc_hd__decap_3
X_7256_ _7357_/CLK _7256_/D _6536_/Y VGND VGND VPWR VPWR _7256_/Q sky130_fd_sc_hd__dfrtp_2
X_4468_ _7009_/Q _5152_/B _5595_/B VGND VGND VPWR VPWR _4468_/X sky130_fd_sc_hd__o21a_2
XFILLER_89_169 VGND VGND VPWR VPWR sky130_fd_sc_hd__fill_2
X_7187_ _7349_/CLK _7187_/D _6467_/Y VGND VGND VPWR VPWR _7187_/Q sky130_fd_sc_hd__dfrtp_2
X_3419_ _7123_/Q _3407_/X _3413_/X _3418_/X VGND VGND VPWR VPWR _3419_/Y sky130_fd_sc_hd__a211oi_2
XFILLER_100_620 VGND VGND VPWR VPWR sky130_fd_sc_hd__decap_3
XFILLER_98_681 VGND VGND VPWR VPWR sky130_fd_sc_hd__decap_3
X_4399_ _7370_/Q _4419_/B1 _4398_/X _4429_/C1 VGND VGND VPWR VPWR _4399_/X sky130_fd_sc_hd__a211o_2
XTAP_TAPCELL_ROW_5_324 VGND VPWR sky130_fd_sc_hd__tapvpwrvgnd_1
XFILLER_46_707 VGND VGND VPWR VPWR sky130_fd_sc_hd__decap_3
XFILLER_58_545 VGND VGND VPWR VPWR sky130_fd_sc_hd__decap_3
XFILLER_85_320 VGND VGND VPWR VPWR sky130_fd_sc_hd__decap_3
XFILLER_85_342 VGND VGND VPWR VPWR sky130_fd_sc_hd__decap_3
XFILLER_97_180 VGND VGND VPWR VPWR sky130_fd_sc_hd__decap_3
Xhold1010 _6708_/Q VGND VGND VPWR VPWR _5717_/A1 sky130_fd_sc_hd__dlygate4sd3_1
Xhold1021 _6713_/Q VGND VGND VPWR VPWR _5727_/A1 sky130_fd_sc_hd__dlygate4sd3_1
Xhold1032 _7311_/Q VGND VGND VPWR VPWR _4536_/A1 sky130_fd_sc_hd__dlygate4sd3_1
XFILLER_100_675 VGND VGND VPWR VPWR sky130_fd_sc_hd__decap_3
XFILLER_45_206 VGND VGND VPWR VPWR sky130_fd_sc_hd__decap_3
XFILLER_58_578 VGND VGND VPWR VPWR sky130_fd_sc_hd__fill_2
XFILLER_85_364 VGND VGND VPWR VPWR sky130_fd_sc_hd__decap_3
Xhold1043 _7384_/Q VGND VGND VPWR VPWR _3868_/A1 sky130_fd_sc_hd__dlygate4sd3_1
Xhold1054 _7024_/Q VGND VGND VPWR VPWR _5607_/A sky130_fd_sc_hd__dlygate4sd3_1
Xhold1065 _7383_/Q VGND VGND VPWR VPWR _3875_/A1 sky130_fd_sc_hd__dlygate4sd3_1
Xhold1076 _7022_/Q VGND VGND VPWR VPWR _5611_/A sky130_fd_sc_hd__dlygate4sd3_1
XPHY_EDGE_ROW_116_Left_236 VGND VGND VPWR VPWR sky130_fd_sc_hd__decap_3
XFILLER_26_431 VGND VGND VPWR VPWR sky130_fd_sc_hd__decap_3
XFILLER_73_537 VGND VGND VPWR VPWR sky130_fd_sc_hd__decap_3
Xhold1087 _7037_/Q VGND VGND VPWR VPWR _5583_/A0 sky130_fd_sc_hd__dlygate4sd3_1
Xhold1098 _7187_/Q VGND VGND VPWR VPWR _5284_/A0 sky130_fd_sc_hd__dlygate4sd3_1
XFILLER_14_604 VGND VGND VPWR VPWR sky130_fd_sc_hd__decap_3
XFILLER_26_464 VGND VGND VPWR VPWR sky130_fd_sc_hd__fill_1
XFILLER_14_637 VGND VGND VPWR VPWR sky130_fd_sc_hd__decap_3
XFILLER_14_648 VGND VGND VPWR VPWR sky130_fd_sc_hd__decap_3
XFILLER_26_486 VGND VGND VPWR VPWR sky130_fd_sc_hd__decap_3
XFILLER_26_88 VGND VGND VPWR VPWR sky130_fd_sc_hd__decap_3
XFILLER_53_261 VGND VGND VPWR VPWR sky130_fd_sc_hd__decap_3
XFILLER_13_136 VGND VGND VPWR VPWR sky130_fd_sc_hd__decap_3
XFILLER_13_169 VGND VGND VPWR VPWR sky130_fd_sc_hd__fill_1
XFILLER_21_180 VGND VGND VPWR VPWR sky130_fd_sc_hd__decap_3
XFILLER_22_681 VGND VGND VPWR VPWR sky130_fd_sc_hd__decap_3
XFILLER_5_302 VGND VGND VPWR VPWR sky130_fd_sc_hd__decap_3
XFILLER_5_335 VGND VGND VPWR VPWR sky130_fd_sc_hd__fill_1
XFILLER_5_346 VGND VGND VPWR VPWR sky130_fd_sc_hd__decap_3
XFILLER_107_252 VGND VGND VPWR VPWR sky130_fd_sc_hd__fill_1
XFILLER_5_379 VGND VGND VPWR VPWR sky130_fd_sc_hd__decap_3
XFILLER_107_274 VGND VGND VPWR VPWR sky130_fd_sc_hd__decap_3
XFILLER_107_296 VGND VGND VPWR VPWR sky130_fd_sc_hd__decap_3
XFILLER_1_541 VGND VGND VPWR VPWR sky130_fd_sc_hd__decap_3
XFILLER_110_417 VGND VGND VPWR VPWR sky130_fd_sc_hd__decap_3
XFILLER_1_585 VGND VGND VPWR VPWR sky130_fd_sc_hd__decap_3
XFILLER_49_501 VGND VGND VPWR VPWR sky130_fd_sc_hd__decap_3
XFILLER_95_128 VGND VGND VPWR VPWR sky130_fd_sc_hd__decap_3
XFILLER_67_73 VGND VGND VPWR VPWR sky130_fd_sc_hd__decap_3
XFILLER_67_84 VGND VGND VPWR VPWR sky130_fd_sc_hd__decap_3
XFILLER_88_180 VGND VGND VPWR VPWR sky130_fd_sc_hd__decap_3
XFILLER_36_206 VGND VGND VPWR VPWR sky130_fd_sc_hd__decap_3
XFILLER_91_312 VGND VGND VPWR VPWR sky130_fd_sc_hd__decap_3
XTAP_TAPCELL_ROW_108_1608 VGND VPWR sky130_fd_sc_hd__tapvpwrvgnd_1
XFILLER_91_378 VGND VGND VPWR VPWR sky130_fd_sc_hd__decap_3
XFILLER_32_412 VGND VGND VPWR VPWR sky130_fd_sc_hd__decap_3
XFILLER_44_261 VGND VGND VPWR VPWR sky130_fd_sc_hd__decap_3
XFILLER_60_710 VGND VGND VPWR VPWR sky130_fd_sc_hd__decap_3
XFILLER_83_72 VGND VGND VPWR VPWR sky130_fd_sc_hd__decap_3
XFILLER_20_607 VGND VGND VPWR VPWR sky130_fd_sc_hd__decap_3
XFILLER_32_445 VGND VGND VPWR VPWR sky130_fd_sc_hd__decap_3
XTAP_TAPCELL_ROW_67_1095 VGND VPWR sky130_fd_sc_hd__tapvpwrvgnd_1
X_3770_ _3770_/A1 _3857_/A2 _4944_/B VGND VGND VPWR VPWR _7393_/D sky130_fd_sc_hd__a21o_2
XTAP_TAPCELL_ROW_80_1262 VGND VPWR sky130_fd_sc_hd__tapvpwrvgnd_1
XTAP_TAPCELL_ROW_30_635 VGND VPWR sky130_fd_sc_hd__tapvpwrvgnd_1
XFILLER_9_641 VGND VGND VPWR VPWR sky130_fd_sc_hd__decap_3
XFILLER_8_162 VGND VGND VPWR VPWR sky130_fd_sc_hd__decap_3
XTAP_TAPCELL_ROW_119_1759 VGND VPWR sky130_fd_sc_hd__tapvpwrvgnd_1
XTAP_TAPCELL_ROW_119_1748 VGND VPWR sky130_fd_sc_hd__tapvpwrvgnd_1
XFILLER_9_685 VGND VGND VPWR VPWR sky130_fd_sc_hd__decap_3
XFILLER_66_3 VGND VGND VPWR VPWR sky130_fd_sc_hd__fill_2
XFILLER_114_701 VGND VGND VPWR VPWR sky130_fd_sc_hd__decap_3
X_5371_ _5371_/A0 _4771_/X _5379_/S VGND VGND VPWR VPWR _7147_/D sky130_fd_sc_hd__mux2_2
XTAP_TAPCELL_ROW_10_381 VGND VPWR sky130_fd_sc_hd__tapvpwrvgnd_1
XFILLER_99_412 VGND VGND VPWR VPWR sky130_fd_sc_hd__decap_3
XFILLER_113_211 VGND VGND VPWR VPWR sky130_fd_sc_hd__decap_3
XFILLER_113_222 VGND VGND VPWR VPWR sky130_fd_sc_hd__fill_2
X_7110_ _7333_/CLK _7110_/D _6390_/Y VGND VGND VPWR VPWR _7110_/Q sky130_fd_sc_hd__dfrtp_2
X_4322_ _7290_/Q _5080_/S _4352_/B1 _7162_/Q _4321_/X VGND VGND VPWR VPWR _4322_/X
+ sky130_fd_sc_hd__a221o_2
XFILLER_99_445 VGND VGND VPWR VPWR sky130_fd_sc_hd__decap_3
X_7041_ _7396_/CLK _7041_/D _6321_/Y VGND VGND VPWR VPWR _7041_/Q sky130_fd_sc_hd__dfrtp_2
X_4253_ _7389_/Q _4261_/A2 _5028_/S _7293_/Q _4252_/X VGND VGND VPWR VPWR _4253_/X
+ sky130_fd_sc_hd__a221o_2
XFILLER_86_106 VGND VGND VPWR VPWR sky130_fd_sc_hd__fill_1
XFILLER_86_117 VGND VGND VPWR VPWR sky130_fd_sc_hd__decap_3
XTAP_TAPCELL_ROW_91_1391 VGND VPWR sky130_fd_sc_hd__tapvpwrvgnd_1
XFILLER_99_489 VGND VGND VPWR VPWR sky130_fd_sc_hd__decap_3
XFILLER_28_707 VGND VGND VPWR VPWR sky130_fd_sc_hd__decap_3
X_4184_ _7296_/Q _5080_/S _4417_/B1 _7104_/Q _4183_/X VGND VGND VPWR VPWR _4185_/C
+ sky130_fd_sc_hd__a221o_2
XFILLER_67_375 VGND VGND VPWR VPWR sky130_fd_sc_hd__decap_3
XFILLER_95_662 VGND VGND VPWR VPWR sky130_fd_sc_hd__decap_3
XFILLER_95_673 VGND VGND VPWR VPWR sky130_fd_sc_hd__decap_3
XFILLER_103_38 VGND VGND VPWR VPWR sky130_fd_sc_hd__decap_3
XFILLER_27_228 VGND VGND VPWR VPWR sky130_fd_sc_hd__decap_3
XTAP_TAPCELL_ROW_38_735 VGND VPWR sky130_fd_sc_hd__tapvpwrvgnd_1
XFILLER_42_209 VGND VGND VPWR VPWR sky130_fd_sc_hd__decap_3
XFILLER_23_434 VGND VGND VPWR VPWR sky130_fd_sc_hd__fill_1
Xplace570 _6632_/A VGND VGND VPWR VPWR _6626_/A sky130_fd_sc_hd__buf_2
X_6825_ clkload4/A _6825_/D VGND VGND VPWR VPWR _6825_/Q sky130_fd_sc_hd__dfxtp_2
XTAP_TAPCELL_ROW_18_481 VGND VPWR sky130_fd_sc_hd__tapvpwrvgnd_1
XFILLER_11_629 VGND VGND VPWR VPWR sky130_fd_sc_hd__decap_3
XFILLER_23_478 VGND VGND VPWR VPWR sky130_fd_sc_hd__decap_3
XFILLER_50_253 VGND VGND VPWR VPWR sky130_fd_sc_hd__decap_3
X_6756_ _6906_/CLK _6756_/D VGND VGND VPWR VPWR _6756_/Q sky130_fd_sc_hd__dfxtp_2
X_3968_ _7356_/Q _4510_/A0 _3975_/S VGND VGND VPWR VPWR _7356_/D sky130_fd_sc_hd__mux2_2
XFILLER_10_139 VGND VGND VPWR VPWR sky130_fd_sc_hd__fill_1
XFILLER_12_35 VGND VGND VPWR VPWR sky130_fd_sc_hd__fill_1
X_6687_ _6944_/CLK _6687_/D VGND VGND VPWR VPWR _6687_/Q sky130_fd_sc_hd__dfxtp_2
X_3899_ _6693_/Q _3925_/A2 _3922_/B1 _6871_/Q _3746_/C VGND VGND VPWR VPWR _3899_/X
+ sky130_fd_sc_hd__a221o_2
XFILLER_12_79 VGND VGND VPWR VPWR sky130_fd_sc_hd__decap_3
XFILLER_105_712 VGND VGND VPWR VPWR sky130_fd_sc_hd__fill_2
XFILLER_2_305 VGND VGND VPWR VPWR sky130_fd_sc_hd__decap_3
X_5569_ _5569_/A1 _4960_/A _4910_/B VGND VGND VPWR VPWR _7048_/D sky130_fd_sc_hd__a21bo_2
XFILLER_104_211 VGND VGND VPWR VPWR sky130_fd_sc_hd__decap_3
XFILLER_117_594 VGND VGND VPWR VPWR sky130_fd_sc_hd__decap_3
XFILLER_2_338 VGND VGND VPWR VPWR sky130_fd_sc_hd__decap_3
X_7308_ _7373_/CLK _7308_/D _6588_/Y VGND VGND VPWR VPWR _7308_/Q sky130_fd_sc_hd__dfrtp_2
XFILLER_104_233 VGND VGND VPWR VPWR sky130_fd_sc_hd__decap_3
XFILLER_104_277 VGND VGND VPWR VPWR sky130_fd_sc_hd__decap_3
XFILLER_77_106 VGND VGND VPWR VPWR sky130_fd_sc_hd__decap_3
XFILLER_77_128 VGND VGND VPWR VPWR sky130_fd_sc_hd__decap_3
XFILLER_78_629 VGND VGND VPWR VPWR sky130_fd_sc_hd__decap_3
X_7239_ _7371_/CLK _7239_/D _6519_/Y VGND VGND VPWR VPWR _7239_/Q sky130_fd_sc_hd__dfrtp_2
XFILLER_86_651 VGND VGND VPWR VPWR sky130_fd_sc_hd__decap_3
XFILLER_100_461 VGND VGND VPWR VPWR sky130_fd_sc_hd__decap_3
XFILLER_85_161 VGND VGND VPWR VPWR sky130_fd_sc_hd__decap_3
XFILLER_86_684 VGND VGND VPWR VPWR sky130_fd_sc_hd__decap_3
XFILLER_92_109 VGND VGND VPWR VPWR sky130_fd_sc_hd__decap_3
XFILLER_18_239 VGND VGND VPWR VPWR sky130_fd_sc_hd__decap_3
XFILLER_37_76 VGND VGND VPWR VPWR sky130_fd_sc_hd__decap_3
XFILLER_58_386 VGND VGND VPWR VPWR sky130_fd_sc_hd__fill_1
XFILLER_73_323 VGND VGND VPWR VPWR sky130_fd_sc_hd__decap_3
XFILLER_73_334 VGND VGND VPWR VPWR sky130_fd_sc_hd__fill_2
XFILLER_85_172 VGND VGND VPWR VPWR sky130_fd_sc_hd__fill_1
XFILLER_85_183 VGND VGND VPWR VPWR sky130_fd_sc_hd__decap_3
XFILLER_26_272 VGND VGND VPWR VPWR sky130_fd_sc_hd__decap_3
XFILLER_42_710 VGND VGND VPWR VPWR sky130_fd_sc_hd__decap_3
XFILLER_54_581 VGND VGND VPWR VPWR sky130_fd_sc_hd__decap_3
XFILLER_14_445 VGND VGND VPWR VPWR sky130_fd_sc_hd__decap_3
XFILLER_41_220 VGND VGND VPWR VPWR sky130_fd_sc_hd__decap_3
XFILLER_41_231 VGND VGND VPWR VPWR sky130_fd_sc_hd__fill_2
XTAP_TAPCELL_ROW_103_1549 VGND VPWR sky130_fd_sc_hd__tapvpwrvgnd_1
XFILLER_10_640 VGND VGND VPWR VPWR sky130_fd_sc_hd__decap_3
XFILLER_10_651 VGND VGND VPWR VPWR sky130_fd_sc_hd__decap_3
XFILLER_10_684 VGND VGND VPWR VPWR sky130_fd_sc_hd__decap_3
XFILLER_6_622 VGND VGND VPWR VPWR sky130_fd_sc_hd__decap_3
XFILLER_6_666 VGND VGND VPWR VPWR sky130_fd_sc_hd__decap_3
XFILLER_6_699 VGND VGND VPWR VPWR sky130_fd_sc_hd__fill_1
XFILLER_69_607 VGND VGND VPWR VPWR sky130_fd_sc_hd__decap_3
XFILLER_96_404 VGND VGND VPWR VPWR sky130_fd_sc_hd__decap_3
XTAP_TAPCELL_ROW_114_1689 VGND VPWR sky130_fd_sc_hd__tapvpwrvgnd_1
XTAP_TAPCELL_ROW_114_1678 VGND VPWR sky130_fd_sc_hd__tapvpwrvgnd_1
XFILLER_69_629 VGND VGND VPWR VPWR sky130_fd_sc_hd__decap_3
XFILLER_78_94 VGND VGND VPWR VPWR sky130_fd_sc_hd__decap_3
XFILLER_96_426 VGND VGND VPWR VPWR sky130_fd_sc_hd__decap_3
XFILLER_49_331 VGND VGND VPWR VPWR sky130_fd_sc_hd__fill_2
XFILLER_68_139 VGND VGND VPWR VPWR sky130_fd_sc_hd__fill_1
XFILLER_96_448 VGND VGND VPWR VPWR sky130_fd_sc_hd__decap_3
XFILLER_64_301 VGND VGND VPWR VPWR sky130_fd_sc_hd__decap_3
XFILLER_77_662 VGND VGND VPWR VPWR sky130_fd_sc_hd__decap_3
XFILLER_77_673 VGND VGND VPWR VPWR sky130_fd_sc_hd__decap_3
XFILLER_83_109 VGND VGND VPWR VPWR sky130_fd_sc_hd__decap_3
XFILLER_92_610 VGND VGND VPWR VPWR sky130_fd_sc_hd__decap_3
XFILLER_64_312 VGND VGND VPWR VPWR sky130_fd_sc_hd__decap_3
XFILLER_76_172 VGND VGND VPWR VPWR sky130_fd_sc_hd__fill_1
XFILLER_92_643 VGND VGND VPWR VPWR sky130_fd_sc_hd__fill_1
XTAP_TAPCELL_ROW_69_1124 VGND VPWR sky130_fd_sc_hd__tapvpwrvgnd_1
XFILLER_24_209 VGND VGND VPWR VPWR sky130_fd_sc_hd__decap_3
XFILLER_52_507 VGND VGND VPWR VPWR sky130_fd_sc_hd__decap_3
XFILLER_52_518 VGND VGND VPWR VPWR sky130_fd_sc_hd__decap_3
XFILLER_64_356 VGND VGND VPWR VPWR sky130_fd_sc_hd__decap_3
XFILLER_91_142 VGND VGND VPWR VPWR sky130_fd_sc_hd__decap_3
XFILLER_92_654 VGND VGND VPWR VPWR sky130_fd_sc_hd__decap_3
XFILLER_91_175 VGND VGND VPWR VPWR sky130_fd_sc_hd__decap_3
XFILLER_92_687 VGND VGND VPWR VPWR sky130_fd_sc_hd__decap_3
X_4940_ _4814_/A _4937_/Y _4939_/X VGND VGND VPWR VPWR _4940_/Y sky130_fd_sc_hd__o21ai_2
X_4871_ _4845_/A _4643_/Y _4841_/Y _4948_/A VGND VGND VPWR VPWR _4871_/Y sky130_fd_sc_hd__a31oi_2
XFILLER_32_253 VGND VGND VPWR VPWR sky130_fd_sc_hd__decap_3
X_6610_ _6610_/A VGND VGND VPWR VPWR _6610_/Y sky130_fd_sc_hd__inv_2
X_3822_ _3822_/A1 _3857_/A2 _5010_/C VGND VGND VPWR VPWR _7389_/D sky130_fd_sc_hd__a21o_2
XTAP_TAPCELL_ROW_15_451 VGND VPWR sky130_fd_sc_hd__tapvpwrvgnd_1
XTAP_TAPCELL_ROW_15_440 VGND VPWR sky130_fd_sc_hd__tapvpwrvgnd_1
XFILLER_20_448 VGND VGND VPWR VPWR sky130_fd_sc_hd__fill_2
X_6541_ _6544_/A VGND VGND VPWR VPWR _6541_/Y sky130_fd_sc_hd__inv_2
XTAP_TAPCELL_ROW_43_793 VGND VPWR sky130_fd_sc_hd__tapvpwrvgnd_1
X_3753_ _3682_/A _3752_/X _4791_/A1 VGND VGND VPWR VPWR _3753_/X sky130_fd_sc_hd__a21o_2
XFILLER_9_471 VGND VGND VPWR VPWR sky130_fd_sc_hd__decap_3
X_6472_ _6664_/A VGND VGND VPWR VPWR _6472_/Y sky130_fd_sc_hd__inv_2
X_3684_ _3684_/A1 _3857_/A2 _3683_/Y VGND VGND VPWR VPWR _7404_/D sky130_fd_sc_hd__a21bo_2
XFILLER_9_482 VGND VGND VPWR VPWR sky130_fd_sc_hd__decap_3
XFILLER_106_509 VGND VGND VPWR VPWR sky130_fd_sc_hd__decap_3
X_5423_ _5423_/A0 _5139_/X _5427_/S VGND VGND VPWR VPWR _7122_/D sky130_fd_sc_hd__mux2_2
X_5354_ _5354_/A0 _5139_/X _5360_/S VGND VGND VPWR VPWR _7154_/D sky130_fd_sc_hd__mux2_2
XTAP_TAPCELL_ROW_93_1420 VGND VPWR sky130_fd_sc_hd__tapvpwrvgnd_1
XFILLER_99_220 VGND VGND VPWR VPWR sky130_fd_sc_hd__fill_1
XFILLER_102_704 VGND VGND VPWR VPWR sky130_fd_sc_hd__decap_3
X_4305_ _7064_/Q _4305_/B VGND VGND VPWR VPWR _4364_/B sky130_fd_sc_hd__nor2_2
XFILLER_99_242 VGND VGND VPWR VPWR sky130_fd_sc_hd__decap_3
XFILLER_101_203 VGND VGND VPWR VPWR sky130_fd_sc_hd__decap_3
XFILLER_59_128 VGND VGND VPWR VPWR sky130_fd_sc_hd__decap_3
XFILLER_101_225 VGND VGND VPWR VPWR sky130_fd_sc_hd__decap_3
X_7024_ _7406_/CLK _7024_/D _6304_/Y VGND VGND VPWR VPWR _7024_/Q sky130_fd_sc_hd__dfrtp_2
X_4236_ _7163_/Q _4339_/B1 _4234_/X _4235_/X VGND VGND VPWR VPWR _4236_/X sky130_fd_sc_hd__a211o_2
XFILLER_114_26 VGND VGND VPWR VPWR sky130_fd_sc_hd__fill_2
XFILLER_55_301 VGND VGND VPWR VPWR sky130_fd_sc_hd__fill_2
XFILLER_68_651 VGND VGND VPWR VPWR sky130_fd_sc_hd__decap_3
XFILLER_68_684 VGND VGND VPWR VPWR sky130_fd_sc_hd__decap_3
XFILLER_74_109 VGND VGND VPWR VPWR sky130_fd_sc_hd__decap_3
X_4167_ _7393_/Q _4437_/B1 _4979_/S _7297_/Q _4166_/X VGND VGND VPWR VPWR _4167_/X
+ sky130_fd_sc_hd__a221o_2
XFILLER_114_59 VGND VGND VPWR VPWR sky130_fd_sc_hd__decap_3
XFILLER_67_161 VGND VGND VPWR VPWR sky130_fd_sc_hd__decap_3
XFILLER_67_183 VGND VGND VPWR VPWR sky130_fd_sc_hd__decap_3
XFILLER_83_632 VGND VGND VPWR VPWR sky130_fd_sc_hd__decap_3
XFILLER_82_153 VGND VGND VPWR VPWR sky130_fd_sc_hd__decap_3
XFILLER_83_665 VGND VGND VPWR VPWR sky130_fd_sc_hd__decap_3
XFILLER_83_676 VGND VGND VPWR VPWR sky130_fd_sc_hd__decap_3
X_4098_ _7333_/Q _3952_/S _4338_/B1 _7365_/Q _4429_/C1 VGND VGND VPWR VPWR _4098_/X
+ sky130_fd_sc_hd__a221o_2
XFILLER_24_710 VGND VGND VPWR VPWR sky130_fd_sc_hd__decap_3
XFILLER_55_378 VGND VGND VPWR VPWR sky130_fd_sc_hd__decap_3
XFILLER_82_186 VGND VGND VPWR VPWR sky130_fd_sc_hd__decap_3
XFILLER_36_592 VGND VGND VPWR VPWR sky130_fd_sc_hd__decap_3
XFILLER_82_197 VGND VGND VPWR VPWR sky130_fd_sc_hd__decap_3
XFILLER_23_242 VGND VGND VPWR VPWR sky130_fd_sc_hd__decap_3
XFILLER_90_29 VGND VGND VPWR VPWR sky130_fd_sc_hd__decap_3
X_6808_ _6944_/CLK _6808_/D VGND VGND VPWR VPWR _6808_/Q sky130_fd_sc_hd__dfxtp_2
XFILLER_23_297 VGND VGND VPWR VPWR sky130_fd_sc_hd__decap_3
XFILLER_7_408 VGND VGND VPWR VPWR sky130_fd_sc_hd__fill_2
X_6739_ clkload5/A _6739_/D VGND VGND VPWR VPWR _6739_/Q sky130_fd_sc_hd__dfxtp_2
XFILLER_3_647 VGND VGND VPWR VPWR sky130_fd_sc_hd__decap_3
XFILLER_105_564 VGND VGND VPWR VPWR sky130_fd_sc_hd__decap_3
XFILLER_105_597 VGND VGND VPWR VPWR sky130_fd_sc_hd__decap_3
XFILLER_48_64 VGND VGND VPWR VPWR sky130_fd_sc_hd__decap_3
XFILLER_58_150 VGND VGND VPWR VPWR sky130_fd_sc_hd__decap_3
XFILLER_59_662 VGND VGND VPWR VPWR sky130_fd_sc_hd__decap_3
XFILLER_59_673 VGND VGND VPWR VPWR sky130_fd_sc_hd__decap_3
XFILLER_74_621 VGND VGND VPWR VPWR sky130_fd_sc_hd__decap_3
XFILLER_19_559 VGND VGND VPWR VPWR sky130_fd_sc_hd__fill_1
XFILLER_74_654 VGND VGND VPWR VPWR sky130_fd_sc_hd__decap_3
XFILLER_27_570 VGND VGND VPWR VPWR sky130_fd_sc_hd__fill_1
XFILLER_34_529 VGND VGND VPWR VPWR sky130_fd_sc_hd__decap_3
XFILLER_46_389 VGND VGND VPWR VPWR sky130_fd_sc_hd__decap_3
XFILLER_74_687 VGND VGND VPWR VPWR sky130_fd_sc_hd__decap_3
XFILLER_61_337 VGND VGND VPWR VPWR sky130_fd_sc_hd__decap_3
XFILLER_14_242 VGND VGND VPWR VPWR sky130_fd_sc_hd__decap_3
XFILLER_14_253 VGND VGND VPWR VPWR sky130_fd_sc_hd__decap_3
XFILLER_30_713 VGND VGND VPWR VPWR sky130_fd_sc_hd__fill_1
XTAP_TAPCELL_ROW_64_1054 VGND VPWR sky130_fd_sc_hd__tapvpwrvgnd_1
XFILLER_14_286 VGND VGND VPWR VPWR sky130_fd_sc_hd__decap_3
XTAP_TAPCELL_ROW_12_410 VGND VPWR sky130_fd_sc_hd__tapvpwrvgnd_1
XFILLER_80_73 VGND VGND VPWR VPWR sky130_fd_sc_hd__decap_3
XTAP_TAPCELL_ROW_40_763 VGND VPWR sky130_fd_sc_hd__tapvpwrvgnd_1
XTAP_TAPCELL_ROW_40_752 VGND VPWR sky130_fd_sc_hd__tapvpwrvgnd_1
XTAP_TAPCELL_ROW_116_1707 VGND VPWR sky130_fd_sc_hd__tapvpwrvgnd_1
XFILLER_6_441 VGND VGND VPWR VPWR sky130_fd_sc_hd__decap_3
Xhold909 _6803_/Q VGND VGND VPWR VPWR _6803_/D sky130_fd_sc_hd__dlygate4sd3_1
XFILLER_6_474 VGND VGND VPWR VPWR sky130_fd_sc_hd__fill_2
XFILLER_89_60 VGND VGND VPWR VPWR sky130_fd_sc_hd__fill_2
XFILLER_89_82 VGND VGND VPWR VPWR sky130_fd_sc_hd__decap_3
XFILLER_69_404 VGND VGND VPWR VPWR sky130_fd_sc_hd__decap_3
XTAP_TAPCELL_ROW_75_1194 VGND VPWR sky130_fd_sc_hd__tapvpwrvgnd_1
XFILLER_111_545 VGND VGND VPWR VPWR sky130_fd_sc_hd__decap_3
XFILLER_69_437 VGND VGND VPWR VPWR sky130_fd_sc_hd__decap_3
X_5070_ _5073_/A _5050_/X _5053_/Y VGND VGND VPWR VPWR _5075_/A sky130_fd_sc_hd__o21a_2
XFILLER_111_567 VGND VGND VPWR VPWR sky130_fd_sc_hd__decap_3
XFILLER_56_109 VGND VGND VPWR VPWR sky130_fd_sc_hd__decap_3
XFILLER_96_256 VGND VGND VPWR VPWR sky130_fd_sc_hd__fill_2
XFILLER_37_301 VGND VGND VPWR VPWR sky130_fd_sc_hd__decap_3
XFILLER_49_183 VGND VGND VPWR VPWR sky130_fd_sc_hd__decap_3
XFILLER_65_632 VGND VGND VPWR VPWR sky130_fd_sc_hd__decap_3
XFILLER_37_334 VGND VGND VPWR VPWR sky130_fd_sc_hd__fill_2
XFILLER_65_665 VGND VGND VPWR VPWR sky130_fd_sc_hd__decap_3
XFILLER_65_676 VGND VGND VPWR VPWR sky130_fd_sc_hd__decap_3
XTAP_TAPCELL_ROW_48_863 VGND VPWR sky130_fd_sc_hd__tapvpwrvgnd_1
XTAP_TAPCELL_ROW_48_852 VGND VPWR sky130_fd_sc_hd__tapvpwrvgnd_1
XFILLER_52_315 VGND VGND VPWR VPWR sky130_fd_sc_hd__decap_3
XFILLER_64_153 VGND VGND VPWR VPWR sky130_fd_sc_hd__decap_3
XFILLER_64_186 VGND VGND VPWR VPWR sky130_fd_sc_hd__decap_3
XFILLER_80_624 VGND VGND VPWR VPWR sky130_fd_sc_hd__decap_3
XFILLER_92_495 VGND VGND VPWR VPWR sky130_fd_sc_hd__decap_3
XFILLER_18_592 VGND VGND VPWR VPWR sky130_fd_sc_hd__decap_3
XFILLER_80_657 VGND VGND VPWR VPWR sky130_fd_sc_hd__decap_3
X_4923_ _4920_/A _4922_/X _4969_/B VGND VGND VPWR VPWR _4923_/Y sky130_fd_sc_hd__o21ai_2
X_4854_ _4764_/B _4096_/A _4633_/A _5101_/A VGND VGND VPWR VPWR _4854_/X sky130_fd_sc_hd__o22a_2
X_4785_ _4785_/A _4811_/B VGND VGND VPWR VPWR _4795_/B sky130_fd_sc_hd__nand2_2
X_3805_ _6948_/Q _3893_/B1 _3883_/B1 _6960_/Q VGND VGND VPWR VPWR _3805_/X sky130_fd_sc_hd__a22o_2
XFILLER_118_100 VGND VGND VPWR VPWR sky130_fd_sc_hd__decap_3
XFILLER_119_623 VGND VGND VPWR VPWR sky130_fd_sc_hd__decap_3
XFILLER_119_645 VGND VGND VPWR VPWR sky130_fd_sc_hd__decap_3
X_6524_ _6652_/A VGND VGND VPWR VPWR _6524_/Y sky130_fd_sc_hd__inv_2
XFILLER_109_15 VGND VGND VPWR VPWR sky130_fd_sc_hd__decap_3
XFILLER_118_144 VGND VGND VPWR VPWR sky130_fd_sc_hd__decap_3
XFILLER_9_290 VGND VGND VPWR VPWR sky130_fd_sc_hd__decap_3
XFILLER_109_48 VGND VGND VPWR VPWR sky130_fd_sc_hd__decap_3
XFILLER_118_177 VGND VGND VPWR VPWR sky130_fd_sc_hd__decap_3
X_6455_ _6617_/A VGND VGND VPWR VPWR _6455_/Y sky130_fd_sc_hd__inv_2
X_6386_ _6610_/A VGND VGND VPWR VPWR _6386_/Y sky130_fd_sc_hd__inv_2
X_3598_ _3598_/A _3611_/B VGND VGND VPWR VPWR _4614_/B sky130_fd_sc_hd__nor2_2
XFILLER_0_606 VGND VGND VPWR VPWR sky130_fd_sc_hd__fill_2
XFILLER_0_617 VGND VGND VPWR VPWR sky130_fd_sc_hd__decap_3
XFILLER_88_713 VGND VGND VPWR VPWR sky130_fd_sc_hd__fill_1
XFILLER_102_545 VGND VGND VPWR VPWR sky130_fd_sc_hd__fill_1
XFILLER_87_223 VGND VGND VPWR VPWR sky130_fd_sc_hd__fill_1
XFILLER_87_234 VGND VGND VPWR VPWR sky130_fd_sc_hd__decap_3
X_5268_ _5268_/A0 _5027_/X _5274_/S VGND VGND VPWR VPWR _7196_/D sky130_fd_sc_hd__mux2_2
XFILLER_102_567 VGND VGND VPWR VPWR sky130_fd_sc_hd__decap_3
XFILLER_102_589 VGND VGND VPWR VPWR sky130_fd_sc_hd__fill_1
XFILLER_87_267 VGND VGND VPWR VPWR sky130_fd_sc_hd__decap_3
X_7007_ _7373_/CLK _7007_/D _6287_/Y VGND VGND VPWR VPWR _7007_/Q sky130_fd_sc_hd__dfrtp_2
X_4219_ _7292_/Q _5080_/S _4267_/B1 _7164_/Q _4218_/X VGND VGND VPWR VPWR _4219_/X
+ sky130_fd_sc_hd__a221o_2
XFILLER_56_610 VGND VGND VPWR VPWR sky130_fd_sc_hd__decap_3
XFILLER_16_507 VGND VGND VPWR VPWR sky130_fd_sc_hd__decap_3
XFILLER_55_142 VGND VGND VPWR VPWR sky130_fd_sc_hd__decap_3
XFILLER_56_643 VGND VGND VPWR VPWR sky130_fd_sc_hd__fill_1
XFILLER_56_654 VGND VGND VPWR VPWR sky130_fd_sc_hd__decap_3
XFILLER_16_518 VGND VGND VPWR VPWR sky130_fd_sc_hd__decap_3
XFILLER_28_389 VGND VGND VPWR VPWR sky130_fd_sc_hd__decap_3
XFILLER_55_175 VGND VGND VPWR VPWR sky130_fd_sc_hd__decap_3
XFILLER_56_687 VGND VGND VPWR VPWR sky130_fd_sc_hd__decap_3
XFILLER_71_613 VGND VGND VPWR VPWR sky130_fd_sc_hd__decap_3
XFILLER_71_635 VGND VGND VPWR VPWR sky130_fd_sc_hd__decap_3
XFILLER_83_473 VGND VGND VPWR VPWR sky130_fd_sc_hd__decap_3
XFILLER_43_337 VGND VGND VPWR VPWR sky130_fd_sc_hd__decap_3
XFILLER_70_112 VGND VGND VPWR VPWR sky130_fd_sc_hd__fill_1
XFILLER_71_668 VGND VGND VPWR VPWR sky130_fd_sc_hd__decap_3
XFILLER_12_713 VGND VGND VPWR VPWR sky130_fd_sc_hd__fill_1
XFILLER_71_679 VGND VGND VPWR VPWR sky130_fd_sc_hd__decap_3
XTAP_TAPCELL_ROW_26_579 VGND VPWR sky130_fd_sc_hd__tapvpwrvgnd_1
XTAP_TAPCELL_ROW_100_1508 VGND VPWR sky130_fd_sc_hd__tapvpwrvgnd_1
XFILLER_24_595 VGND VGND VPWR VPWR sky130_fd_sc_hd__decap_3
XFILLER_34_88 VGND VGND VPWR VPWR sky130_fd_sc_hd__decap_3
XFILLER_11_245 VGND VGND VPWR VPWR sky130_fd_sc_hd__decap_3
XFILLER_109_100 VGND VGND VPWR VPWR sky130_fd_sc_hd__decap_3
XFILLER_109_122 VGND VGND VPWR VPWR sky130_fd_sc_hd__decap_3
XFILLER_11_267 VGND VGND VPWR VPWR sky130_fd_sc_hd__decap_3
XFILLER_11_289 VGND VGND VPWR VPWR sky130_fd_sc_hd__decap_3
XFILLER_109_155 VGND VGND VPWR VPWR sky130_fd_sc_hd__decap_3
XFILLER_3_411 VGND VGND VPWR VPWR sky130_fd_sc_hd__decap_3
XFILLER_105_361 VGND VGND VPWR VPWR sky130_fd_sc_hd__decap_3
XFILLER_112_309 VGND VGND VPWR VPWR sky130_fd_sc_hd__decap_3
XFILLER_105_383 VGND VGND VPWR VPWR sky130_fd_sc_hd__decap_3
XFILLER_3_499 VGND VGND VPWR VPWR sky130_fd_sc_hd__decap_3
XFILLER_59_74 VGND VGND VPWR VPWR sky130_fd_sc_hd__decap_3
XFILLER_78_245 VGND VGND VPWR VPWR sky130_fd_sc_hd__decap_3
XTAP_TAPCELL_ROW_111_1648 VGND VPWR sky130_fd_sc_hd__tapvpwrvgnd_1
XFILLER_66_418 VGND VGND VPWR VPWR sky130_fd_sc_hd__fill_2
XFILLER_78_256 VGND VGND VPWR VPWR sky130_fd_sc_hd__decap_3
XFILLER_78_278 VGND VGND VPWR VPWR sky130_fd_sc_hd__decap_3
XFILLER_47_610 VGND VGND VPWR VPWR sky130_fd_sc_hd__decap_3
XFILLER_47_632 VGND VGND VPWR VPWR sky130_fd_sc_hd__decap_3
XFILLER_93_237 VGND VGND VPWR VPWR sky130_fd_sc_hd__decap_3
XFILLER_19_334 VGND VGND VPWR VPWR sky130_fd_sc_hd__fill_2
XFILLER_47_665 VGND VGND VPWR VPWR sky130_fd_sc_hd__decap_3
XFILLER_75_73 VGND VGND VPWR VPWR sky130_fd_sc_hd__decap_3
XFILLER_34_304 VGND VGND VPWR VPWR sky130_fd_sc_hd__decap_3
XFILLER_46_153 VGND VGND VPWR VPWR sky130_fd_sc_hd__decap_3
XFILLER_47_676 VGND VGND VPWR VPWR sky130_fd_sc_hd__decap_3
XFILLER_61_101 VGND VGND VPWR VPWR sky130_fd_sc_hd__decap_3
XFILLER_75_84 VGND VGND VPWR VPWR sky130_fd_sc_hd__decap_3
XFILLER_46_186 VGND VGND VPWR VPWR sky130_fd_sc_hd__decap_3
XFILLER_46_197 VGND VGND VPWR VPWR sky130_fd_sc_hd__decap_3
XFILLER_61_134 VGND VGND VPWR VPWR sky130_fd_sc_hd__decap_3
XFILLER_62_635 VGND VGND VPWR VPWR sky130_fd_sc_hd__decap_3
XFILLER_62_657 VGND VGND VPWR VPWR sky130_fd_sc_hd__decap_3
XTAP_TAPCELL_ROW_45_822 VGND VPWR sky130_fd_sc_hd__tapvpwrvgnd_1
XFILLER_61_167 VGND VGND VPWR VPWR sky130_fd_sc_hd__fill_1
XFILLER_15_584 VGND VGND VPWR VPWR sky130_fd_sc_hd__decap_3
XFILLER_42_370 VGND VGND VPWR VPWR sky130_fd_sc_hd__decap_3
XFILLER_70_690 VGND VGND VPWR VPWR sky130_fd_sc_hd__decap_3
XFILLER_91_83 VGND VGND VPWR VPWR sky130_fd_sc_hd__decap_3
XFILLER_30_576 VGND VGND VPWR VPWR sky130_fd_sc_hd__decap_3
XFILLER_30_598 VGND VGND VPWR VPWR sky130_fd_sc_hd__decap_3
XFILLER_116_604 VGND VGND VPWR VPWR sky130_fd_sc_hd__decap_3
X_3521_ _3525_/A _3525_/B VGND VGND VPWR VPWR _3618_/C sky130_fd_sc_hd__nand2_2
XFILLER_116_637 VGND VGND VPWR VPWR sky130_fd_sc_hd__decap_3
XFILLER_116_648 VGND VGND VPWR VPWR sky130_fd_sc_hd__decap_3
Xhold706 _6905_/Q VGND VGND VPWR VPWR _6905_/D sky130_fd_sc_hd__dlygate4sd3_1
Xhold717 _6963_/Q VGND VGND VPWR VPWR _6963_/D sky130_fd_sc_hd__dlygate4sd3_1
Xhold728 _6755_/Q VGND VGND VPWR VPWR _6755_/D sky130_fd_sc_hd__dlygate4sd3_1
XTAP_TAPCELL_ROW_77_1223 VGND VPWR sky130_fd_sc_hd__tapvpwrvgnd_1
XFILLER_6_282 VGND VGND VPWR VPWR sky130_fd_sc_hd__decap_3
Xhold739 _6895_/Q VGND VGND VPWR VPWR _6895_/D sky130_fd_sc_hd__dlygate4sd3_1
XFILLER_103_309 VGND VGND VPWR VPWR sky130_fd_sc_hd__fill_2
XFILLER_69_201 VGND VGND VPWR VPWR sky130_fd_sc_hd__decap_3
X_3383_ _5118_/D _3383_/B VGND VGND VPWR VPWR _3562_/A sky130_fd_sc_hd__nor2_2
XFILLER_111_320 VGND VGND VPWR VPWR sky130_fd_sc_hd__fill_2
XFILLER_69_223 VGND VGND VPWR VPWR sky130_fd_sc_hd__fill_1
X_5122_ _5122_/A0 _5121_/X _5142_/S VGND VGND VPWR VPWR _7254_/D sky130_fd_sc_hd__mux2_2
XFILLER_111_353 VGND VGND VPWR VPWR sky130_fd_sc_hd__decap_3
XFILLER_29_109 VGND VGND VPWR VPWR sky130_fd_sc_hd__decap_3
XFILLER_57_407 VGND VGND VPWR VPWR sky130_fd_sc_hd__fill_1
XFILLER_69_245 VGND VGND VPWR VPWR sky130_fd_sc_hd__decap_3
XFILLER_97_576 VGND VGND VPWR VPWR sky130_fd_sc_hd__decap_3
XFILLER_111_375 VGND VGND VPWR VPWR sky130_fd_sc_hd__decap_3
XFILLER_38_610 VGND VGND VPWR VPWR sky130_fd_sc_hd__decap_3
XFILLER_84_215 VGND VGND VPWR VPWR sky130_fd_sc_hd__decap_3
X_5053_ _5073_/A _5050_/X _5020_/A VGND VGND VPWR VPWR _5053_/Y sky130_fd_sc_hd__a21oi_2
XFILLER_38_643 VGND VGND VPWR VPWR sky130_fd_sc_hd__fill_1
XFILLER_38_654 VGND VGND VPWR VPWR sky130_fd_sc_hd__decap_3
XFILLER_84_248 VGND VGND VPWR VPWR sky130_fd_sc_hd__decap_3
XFILLER_38_687 VGND VGND VPWR VPWR sky130_fd_sc_hd__decap_3
XFILLER_65_473 VGND VGND VPWR VPWR sky130_fd_sc_hd__decap_3
XTAP_TAPCELL_ROW_88_1363 VGND VPWR sky130_fd_sc_hd__tapvpwrvgnd_1
XTAP_TAPCELL_ROW_88_1352 VGND VPWR sky130_fd_sc_hd__tapvpwrvgnd_1
XFILLER_111_27 VGND VGND VPWR VPWR sky130_fd_sc_hd__decap_3
XFILLER_25_337 VGND VGND VPWR VPWR sky130_fd_sc_hd__decap_3
XFILLER_37_197 VGND VGND VPWR VPWR sky130_fd_sc_hd__decap_3
XFILLER_52_123 VGND VGND VPWR VPWR sky130_fd_sc_hd__decap_3
XFILLER_53_635 VGND VGND VPWR VPWR sky130_fd_sc_hd__decap_3
XFILLER_52_156 VGND VGND VPWR VPWR sky130_fd_sc_hd__decap_3
XFILLER_53_668 VGND VGND VPWR VPWR sky130_fd_sc_hd__decap_3
XFILLER_53_679 VGND VGND VPWR VPWR sky130_fd_sc_hd__decap_3
XFILLER_80_454 VGND VGND VPWR VPWR sky130_fd_sc_hd__decap_3
XFILLER_40_318 VGND VGND VPWR VPWR sky130_fd_sc_hd__fill_2
XFILLER_80_498 VGND VGND VPWR VPWR sky130_fd_sc_hd__decap_3
X_4906_ _4814_/A _4886_/C _4904_/X _4905_/X VGND VGND VPWR VPWR _4906_/X sky130_fd_sc_hd__o31a_2
X_4837_ _4837_/A0 _4836_/X _4865_/S VGND VGND VPWR VPWR _7271_/D sky130_fd_sc_hd__mux2_2
XTAP_TAPCELL_ROW_23_549 VGND VPWR sky130_fd_sc_hd__tapvpwrvgnd_1
XFILLER_107_604 VGND VGND VPWR VPWR sky130_fd_sc_hd__decap_3
XFILLER_119_464 VGND VGND VPWR VPWR sky130_fd_sc_hd__fill_2
XFILLER_5_709 VGND VGND VPWR VPWR sky130_fd_sc_hd__decap_3
X_4768_ _4762_/Y _4763_/X _4767_/X VGND VGND VPWR VPWR _4768_/Y sky130_fd_sc_hd__o21ai_2
XFILLER_107_626 VGND VGND VPWR VPWR sky130_fd_sc_hd__decap_3
XFILLER_119_486 VGND VGND VPWR VPWR sky130_fd_sc_hd__fill_1
XFILLER_20_24 VGND VGND VPWR VPWR sky130_fd_sc_hd__decap_3
X_6507_ _6631_/A VGND VGND VPWR VPWR _6507_/Y sky130_fd_sc_hd__inv_2
X_4699_ _6986_/Q _6987_/Q _5098_/A VGND VGND VPWR VPWR _5066_/A sky130_fd_sc_hd__and3_2
XTAP_TAPCELL_ROW_99_1492 VGND VPWR sky130_fd_sc_hd__tapvpwrvgnd_1
XFILLER_106_125 VGND VGND VPWR VPWR sky130_fd_sc_hd__decap_3
XFILLER_107_659 VGND VGND VPWR VPWR sky130_fd_sc_hd__decap_3
X_6438_ _6563_/A VGND VGND VPWR VPWR _6438_/Y sky130_fd_sc_hd__inv_2
XFILLER_106_169 VGND VGND VPWR VPWR sky130_fd_sc_hd__decap_3
XFILLER_88_510 VGND VGND VPWR VPWR sky130_fd_sc_hd__fill_1
XFILLER_0_414 VGND VGND VPWR VPWR sky130_fd_sc_hd__decap_3
XFILLER_29_11 VGND VGND VPWR VPWR sky130_fd_sc_hd__fill_1
XFILLER_88_521 VGND VGND VPWR VPWR sky130_fd_sc_hd__decap_3
X_6369_ _6593_/A VGND VGND VPWR VPWR _6369_/Y sky130_fd_sc_hd__inv_2
XFILLER_0_458 VGND VGND VPWR VPWR sky130_fd_sc_hd__decap_3
XFILLER_48_418 VGND VGND VPWR VPWR sky130_fd_sc_hd__fill_2
XFILLER_29_66 VGND VGND VPWR VPWR sky130_fd_sc_hd__fill_2
XFILLER_75_237 VGND VGND VPWR VPWR sky130_fd_sc_hd__decap_3
XFILLER_88_587 VGND VGND VPWR VPWR sky130_fd_sc_hd__fill_1
XFILLER_28_131 VGND VGND VPWR VPWR sky130_fd_sc_hd__decap_3
XFILLER_29_632 VGND VGND VPWR VPWR sky130_fd_sc_hd__decap_3
XFILLER_29_665 VGND VGND VPWR VPWR sky130_fd_sc_hd__decap_3
XFILLER_28_153 VGND VGND VPWR VPWR sky130_fd_sc_hd__decap_3
XFILLER_29_676 VGND VGND VPWR VPWR sky130_fd_sc_hd__decap_3
XFILLER_44_613 VGND VGND VPWR VPWR sky130_fd_sc_hd__decap_3
XFILLER_56_462 VGND VGND VPWR VPWR sky130_fd_sc_hd__fill_1
XTAP_TAPCELL_ROW_3_296 VGND VPWR sky130_fd_sc_hd__tapvpwrvgnd_1
XFILLER_16_326 VGND VGND VPWR VPWR sky130_fd_sc_hd__fill_1
XFILLER_28_197 VGND VGND VPWR VPWR sky130_fd_sc_hd__decap_3
XFILLER_44_657 VGND VGND VPWR VPWR sky130_fd_sc_hd__decap_3
XFILLER_83_281 VGND VGND VPWR VPWR sky130_fd_sc_hd__decap_3
XFILLER_43_178 VGND VGND VPWR VPWR sky130_fd_sc_hd__decap_3
XFILLER_52_690 VGND VGND VPWR VPWR sky130_fd_sc_hd__decap_3
XFILLER_101_71 VGND VGND VPWR VPWR sky130_fd_sc_hd__fill_1
XFILLER_24_392 VGND VGND VPWR VPWR sky130_fd_sc_hd__decap_3
XTAP_TAPCELL_ROW_61_1024 VGND VPWR sky130_fd_sc_hd__tapvpwrvgnd_1
XFILLER_12_587 VGND VGND VPWR VPWR sky130_fd_sc_hd__fill_1
XFILLER_12_598 VGND VGND VPWR VPWR sky130_fd_sc_hd__decap_3
XFILLER_8_569 VGND VGND VPWR VPWR sky130_fd_sc_hd__decap_3
XTAP_TAPCELL_ROW_50_880 VGND VPWR sky130_fd_sc_hd__tapvpwrvgnd_1
XFILLER_6_37 VGND VGND VPWR VPWR sky130_fd_sc_hd__decap_3
XFILLER_113_629 VGND VGND VPWR VPWR sky130_fd_sc_hd__decap_3
XFILLER_3_252 VGND VGND VPWR VPWR sky130_fd_sc_hd__decap_3
XFILLER_98_307 VGND VGND VPWR VPWR sky130_fd_sc_hd__fill_1
XFILLER_98_318 VGND VGND VPWR VPWR sky130_fd_sc_hd__decap_3
XFILLER_106_681 VGND VGND VPWR VPWR sky130_fd_sc_hd__decap_3
XFILLER_79_554 VGND VGND VPWR VPWR sky130_fd_sc_hd__decap_3
XTAP_TAPCELL_ROW_72_1164 VGND VPWR sky130_fd_sc_hd__tapvpwrvgnd_1
XTAP_TAPCELL_ROW_72_1153 VGND VPWR sky130_fd_sc_hd__tapvpwrvgnd_1
XFILLER_39_418 VGND VGND VPWR VPWR sky130_fd_sc_hd__decap_3
XFILLER_66_215 VGND VGND VPWR VPWR sky130_fd_sc_hd__decap_3
XFILLER_86_61 VGND VGND VPWR VPWR sky130_fd_sc_hd__decap_3
XFILLER_66_248 VGND VGND VPWR VPWR sky130_fd_sc_hd__decap_3
XFILLER_86_94 VGND VGND VPWR VPWR sky130_fd_sc_hd__decap_3
XFILLER_94_557 VGND VGND VPWR VPWR sky130_fd_sc_hd__fill_2
XFILLER_34_101 VGND VGND VPWR VPWR sky130_fd_sc_hd__fill_1
XFILLER_35_635 VGND VGND VPWR VPWR sky130_fd_sc_hd__decap_3
XFILLER_62_410 VGND VGND VPWR VPWR sky130_fd_sc_hd__fill_2
XFILLER_62_421 VGND VGND VPWR VPWR sky130_fd_sc_hd__decap_3
XTAP_TAPCELL_ROW_58_980 VGND VPWR sky130_fd_sc_hd__tapvpwrvgnd_1
XFILLER_34_156 VGND VGND VPWR VPWR sky130_fd_sc_hd__decap_3
XFILLER_35_668 VGND VGND VPWR VPWR sky130_fd_sc_hd__decap_3
XFILLER_35_679 VGND VGND VPWR VPWR sky130_fd_sc_hd__decap_3
XFILLER_62_454 VGND VGND VPWR VPWR sky130_fd_sc_hd__decap_3
XFILLER_22_318 VGND VGND VPWR VPWR sky130_fd_sc_hd__decap_3
XFILLER_34_178 VGND VGND VPWR VPWR sky130_fd_sc_hd__decap_3
XFILLER_50_638 VGND VGND VPWR VPWR sky130_fd_sc_hd__decap_3
XTAP_TAPCELL_ROW_83_1293 VGND VPWR sky130_fd_sc_hd__tapvpwrvgnd_1
XFILLER_30_351 VGND VGND VPWR VPWR sky130_fd_sc_hd__decap_3
X_5671_ _5671_/A _5671_/B VGND VGND VPWR VPWR _6983_/D sky130_fd_sc_hd__and2_2
XTAP_TAPCELL_ROW_20_508 VGND VPWR sky130_fd_sc_hd__tapvpwrvgnd_1
X_4622_ _5072_/B _4621_/X _5071_/B VGND VGND VPWR VPWR _4622_/X sky130_fd_sc_hd__a21bo_2
XFILLER_116_412 VGND VGND VPWR VPWR sky130_fd_sc_hd__fill_2
X_7341_ _7342_/CLK _7341_/D _6621_/Y VGND VGND VPWR VPWR _7341_/Q sky130_fd_sc_hd__dfrtp_2
XFILLER_7_591 VGND VGND VPWR VPWR sky130_fd_sc_hd__decap_3
X_7272_ _7374_/CLK _7272_/D _6552_/Y VGND VGND VPWR VPWR _7272_/Q sky130_fd_sc_hd__dfrtp_2
X_4484_ _4484_/A0 _7305_/Q _4488_/S VGND VGND VPWR VPWR _7337_/D sky130_fd_sc_hd__mux2_2
X_3504_ _3501_/X _3502_/X _3630_/A VGND VGND VPWR VPWR _3505_/B sky130_fd_sc_hd__a21oi_2
XFILLER_103_106 VGND VGND VPWR VPWR sky130_fd_sc_hd__decap_3
XFILLER_104_607 VGND VGND VPWR VPWR sky130_fd_sc_hd__decap_3
XFILLER_89_307 VGND VGND VPWR VPWR sky130_fd_sc_hd__decap_3
XFILLER_103_128 VGND VGND VPWR VPWR sky130_fd_sc_hd__decap_3
XFILLER_112_640 VGND VGND VPWR VPWR sky130_fd_sc_hd__decap_3
XFILLER_112_651 VGND VGND VPWR VPWR sky130_fd_sc_hd__decap_3
XFILLER_85_502 VGND VGND VPWR VPWR sky130_fd_sc_hd__fill_2
XFILLER_97_340 VGND VGND VPWR VPWR sky130_fd_sc_hd__decap_3
XFILLER_97_351 VGND VGND VPWR VPWR sky130_fd_sc_hd__decap_3
X_3366_ _3376_/A _3376_/B _3399_/B _5118_/A VGND VGND VPWR VPWR _3366_/X sky130_fd_sc_hd__o211a_2
XFILLER_112_684 VGND VGND VPWR VPWR sky130_fd_sc_hd__decap_3
XFILLER_57_215 VGND VGND VPWR VPWR sky130_fd_sc_hd__decap_3
XFILLER_85_524 VGND VGND VPWR VPWR sky130_fd_sc_hd__decap_3
XFILLER_97_384 VGND VGND VPWR VPWR sky130_fd_sc_hd__decap_3
Xhold1203 _7253_/Q VGND VGND VPWR VPWR _5126_/A0 sky130_fd_sc_hd__dlygate4sd3_1
Xhold1214 _7136_/Q VGND VGND VPWR VPWR _5394_/A0 sky130_fd_sc_hd__dlygate4sd3_1
Xhold1225 _7290_/Q VGND VGND VPWR VPWR _4581_/A sky130_fd_sc_hd__dlygate4sd3_1
X_5105_ _4467_/B _3874_/X _5104_/Y _4606_/A VGND VGND VPWR VPWR _5105_/X sky130_fd_sc_hd__a31o_2
XFILLER_57_237 VGND VGND VPWR VPWR sky130_fd_sc_hd__decap_3
Xhold1236 _7161_/Q VGND VGND VPWR VPWR _5340_/A0 sky130_fd_sc_hd__dlygate4sd3_1
Xhold1247 _7017_/Q VGND VGND VPWR VPWR _5621_/A sky130_fd_sc_hd__dlygate4sd3_1
Xhold1258 _7324_/Q VGND VGND VPWR VPWR _4510_/A0 sky130_fd_sc_hd__dlygate4sd3_1
X_5036_ _5036_/A _4674_/X VGND VGND VPWR VPWR _5038_/A sky130_fd_sc_hd__or2b_2
XFILLER_26_613 VGND VGND VPWR VPWR sky130_fd_sc_hd__decap_3
Xhold1269 _7292_/Q VGND VGND VPWR VPWR _4577_/A sky130_fd_sc_hd__dlygate4sd3_1
XTAP_TAPCELL_ROW_28_608 VGND VPWR sky130_fd_sc_hd__tapvpwrvgnd_1
XFILLER_26_657 VGND VGND VPWR VPWR sky130_fd_sc_hd__decap_3
XTAP_TAPCELL_ROW_0_244 VGND VPWR sky130_fd_sc_hd__tapvpwrvgnd_1
XFILLER_53_454 VGND VGND VPWR VPWR sky130_fd_sc_hd__decap_3
XFILLER_80_240 VGND VGND VPWR VPWR sky130_fd_sc_hd__decap_3
X_6987_ _7396_/CLK _6987_/D _6267_/Y VGND VGND VPWR VPWR _6987_/Q sky130_fd_sc_hd__dfrtp_2
XTAP_TAPCELL_ROW_0_255 VGND VPWR sky130_fd_sc_hd__tapvpwrvgnd_1
XFILLER_15_24 VGND VGND VPWR VPWR sky130_fd_sc_hd__decap_3
XFILLER_40_104 VGND VGND VPWR VPWR sky130_fd_sc_hd__decap_3
XFILLER_41_638 VGND VGND VPWR VPWR sky130_fd_sc_hd__decap_3
XFILLER_53_498 VGND VGND VPWR VPWR sky130_fd_sc_hd__decap_3
XFILLER_80_273 VGND VGND VPWR VPWR sky130_fd_sc_hd__decap_3
XFILLER_34_690 VGND VGND VPWR VPWR sky130_fd_sc_hd__decap_3
XFILLER_40_137 VGND VGND VPWR VPWR sky130_fd_sc_hd__decap_3
XFILLER_80_295 VGND VGND VPWR VPWR sky130_fd_sc_hd__fill_1
XFILLER_21_340 VGND VGND VPWR VPWR sky130_fd_sc_hd__decap_3
XFILLER_107_401 VGND VGND VPWR VPWR sky130_fd_sc_hd__decap_3
XFILLER_107_412 VGND VGND VPWR VPWR sky130_fd_sc_hd__decap_3
XFILLER_5_517 VGND VGND VPWR VPWR sky130_fd_sc_hd__fill_2
XFILLER_107_445 VGND VGND VPWR VPWR sky130_fd_sc_hd__decap_3
XFILLER_119_294 VGND VGND VPWR VPWR sky130_fd_sc_hd__decap_3
XFILLER_5_539 VGND VGND VPWR VPWR sky130_fd_sc_hd__decap_3
XFILLER_107_467 VGND VGND VPWR VPWR sky130_fd_sc_hd__fill_1
XFILLER_0_222 VGND VGND VPWR VPWR sky130_fd_sc_hd__fill_2
XFILLER_103_662 VGND VGND VPWR VPWR sky130_fd_sc_hd__decap_3
XTAP_TAPCELL_ROW_8_355 VGND VPWR sky130_fd_sc_hd__tapvpwrvgnd_1
XFILLER_103_673 VGND VGND VPWR VPWR sky130_fd_sc_hd__decap_3
XFILLER_48_204 VGND VGND VPWR VPWR sky130_fd_sc_hd__decap_3
XFILLER_88_395 VGND VGND VPWR VPWR sky130_fd_sc_hd__decap_3
XFILLER_102_183 VGND VGND VPWR VPWR sky130_fd_sc_hd__decap_3
XFILLER_48_237 VGND VGND VPWR VPWR sky130_fd_sc_hd__decap_3
XFILLER_48_259 VGND VGND VPWR VPWR sky130_fd_sc_hd__decap_3
XFILLER_76_546 VGND VGND VPWR VPWR sky130_fd_sc_hd__decap_3
XFILLER_17_602 VGND VGND VPWR VPWR sky130_fd_sc_hd__decap_3
XFILLER_56_42 VGND VGND VPWR VPWR sky130_fd_sc_hd__fill_2
XFILLER_63_207 VGND VGND VPWR VPWR sky130_fd_sc_hd__decap_3
XFILLER_91_505 VGND VGND VPWR VPWR sky130_fd_sc_hd__decap_3
XFILLER_17_635 VGND VGND VPWR VPWR sky130_fd_sc_hd__decap_3
XFILLER_29_495 VGND VGND VPWR VPWR sky130_fd_sc_hd__decap_3
XFILLER_44_410 VGND VGND VPWR VPWR sky130_fd_sc_hd__fill_1
XFILLER_56_281 VGND VGND VPWR VPWR sky130_fd_sc_hd__fill_1
XFILLER_91_549 VGND VGND VPWR VPWR sky130_fd_sc_hd__decap_3
XFILLER_17_668 VGND VGND VPWR VPWR sky130_fd_sc_hd__decap_3
XFILLER_17_679 VGND VGND VPWR VPWR sky130_fd_sc_hd__decap_3
XFILLER_44_454 VGND VGND VPWR VPWR sky130_fd_sc_hd__decap_3
XFILLER_71_251 VGND VGND VPWR VPWR sky130_fd_sc_hd__decap_3
XTAP_TAPCELL_ROW_55_950 VGND VPWR sky130_fd_sc_hd__tapvpwrvgnd_1
XPHY_EDGE_ROW_113_Right_113 VGND VGND VPWR VPWR sky130_fd_sc_hd__decap_3
XFILLER_32_616 VGND VGND VPWR VPWR sky130_fd_sc_hd__decap_3
XFILLER_72_41 VGND VGND VPWR VPWR sky130_fd_sc_hd__fill_2
XFILLER_72_74 VGND VGND VPWR VPWR sky130_fd_sc_hd__decap_3
XFILLER_72_85 VGND VGND VPWR VPWR sky130_fd_sc_hd__decap_3
XFILLER_12_351 VGND VGND VPWR VPWR sky130_fd_sc_hd__decap_3
XFILLER_40_660 VGND VGND VPWR VPWR sky130_fd_sc_hd__decap_3
XFILLER_72_96 VGND VGND VPWR VPWR sky130_fd_sc_hd__decap_3
XFILLER_12_384 VGND VGND VPWR VPWR sky130_fd_sc_hd__decap_3
XFILLER_40_693 VGND VGND VPWR VPWR sky130_fd_sc_hd__decap_3
XFILLER_8_333 VGND VGND VPWR VPWR sky130_fd_sc_hd__decap_3
XFILLER_8_355 VGND VGND VPWR VPWR sky130_fd_sc_hd__decap_3
Xoutput608 _3525_/B VGND VGND VPWR VPWR instruction_out[14] sky130_fd_sc_hd__clkdlybuf4s25_1
Xoutput619 _5649_/X VGND VGND VPWR VPWR instruction_out[26] sky130_fd_sc_hd__clkdlybuf4s25_1
XFILLER_113_437 VGND VGND VPWR VPWR sky130_fd_sc_hd__decap_3
XFILLER_4_572 VGND VGND VPWR VPWR sky130_fd_sc_hd__decap_3
XFILLER_98_126 VGND VGND VPWR VPWR sky130_fd_sc_hd__decap_3
XFILLER_99_638 VGND VGND VPWR VPWR sky130_fd_sc_hd__decap_3
XFILLER_79_340 VGND VGND VPWR VPWR sky130_fd_sc_hd__decap_3
XFILLER_97_60 VGND VGND VPWR VPWR sky130_fd_sc_hd__decap_3
XFILLER_39_204 VGND VGND VPWR VPWR sky130_fd_sc_hd__decap_3
XFILLER_11_3 VGND VGND VPWR VPWR sky130_fd_sc_hd__decap_3
XFILLER_54_218 VGND VGND VPWR VPWR sky130_fd_sc_hd__decap_3
XFILLER_82_516 VGND VGND VPWR VPWR sky130_fd_sc_hd__decap_3
XFILLER_94_365 VGND VGND VPWR VPWR sky130_fd_sc_hd__decap_3
XFILLER_47_281 VGND VGND VPWR VPWR sky130_fd_sc_hd__fill_2
XFILLER_47_292 VGND VGND VPWR VPWR sky130_fd_sc_hd__fill_1
XFILLER_94_398 VGND VGND VPWR VPWR sky130_fd_sc_hd__decap_3
X_6910_ _6968_/CLK _6910_/D VGND VGND VPWR VPWR _6910_/Q sky130_fd_sc_hd__dfxtp_2
XTAP_TAPCELL_ROW_85_1322 VGND VPWR sky130_fd_sc_hd__tapvpwrvgnd_1
XFILLER_62_240 VGND VGND VPWR VPWR sky130_fd_sc_hd__decap_3
X_6841_ _6906_/CLK _6841_/D VGND VGND VPWR VPWR _6841_/Q sky130_fd_sc_hd__dfxtp_2
XFILLER_22_115 VGND VGND VPWR VPWR sky130_fd_sc_hd__decap_3
XFILLER_23_638 VGND VGND VPWR VPWR sky130_fd_sc_hd__decap_3
XFILLER_62_284 VGND VGND VPWR VPWR sky130_fd_sc_hd__decap_3
XFILLER_16_690 VGND VGND VPWR VPWR sky130_fd_sc_hd__decap_3
XFILLER_22_137 VGND VGND VPWR VPWR sky130_fd_sc_hd__decap_3
X_6772_ clkload9/A _6772_/D VGND VGND VPWR VPWR _6772_/Q sky130_fd_sc_hd__dfxtp_2
XFILLER_31_671 VGND VGND VPWR VPWR sky130_fd_sc_hd__fill_1
X_5723_ _7367_/Q _5723_/A1 _5735_/S VGND VGND VPWR VPWR _6711_/D sky130_fd_sc_hd__mux2_2
XTAP_TAPCELL_ROW_33_666 VGND VPWR sky130_fd_sc_hd__tapvpwrvgnd_1
XFILLER_31_682 VGND VGND VPWR VPWR sky130_fd_sc_hd__decap_3
X_5654_ _5665_/A VGND VGND VPWR VPWR _5654_/Y sky130_fd_sc_hd__inv_2
XFILLER_108_209 VGND VGND VPWR VPWR sky130_fd_sc_hd__decap_3
X_7324_ _7360_/CLK _7324_/D _6604_/Y VGND VGND VPWR VPWR _7324_/Q sky130_fd_sc_hd__dfrtp_2
X_5585_ _5585_/A1 _5587_/B _5106_/X VGND VGND VPWR VPWR _7036_/D sky130_fd_sc_hd__a21o_2
XTAP_TAPCELL_ROW_96_1462 VGND VPWR sky130_fd_sc_hd__tapvpwrvgnd_1
XFILLER_104_404 VGND VGND VPWR VPWR sky130_fd_sc_hd__fill_2
XFILLER_116_253 VGND VGND VPWR VPWR sky130_fd_sc_hd__decap_3
XFILLER_117_26 VGND VGND VPWR VPWR sky130_fd_sc_hd__decap_3
X_4536_ _4536_/A1 _3398_/Y _3488_/X VGND VGND VPWR VPWR _7311_/D sky130_fd_sc_hd__a21o_2
XFILLER_89_137 VGND VGND VPWR VPWR sky130_fd_sc_hd__decap_3
X_7255_ _7387_/CLK _7255_/D _6535_/Y VGND VGND VPWR VPWR _7255_/Q sky130_fd_sc_hd__dfrtp_2
X_4467_ _4467_/A _4467_/B VGND VGND VPWR VPWR _4467_/Y sky130_fd_sc_hd__nor2_2
XFILLER_104_459 VGND VGND VPWR VPWR sky130_fd_sc_hd__decap_3
XFILLER_89_159 VGND VGND VPWR VPWR sky130_fd_sc_hd__decap_3
XFILLER_98_660 VGND VGND VPWR VPWR sky130_fd_sc_hd__decap_3
X_7186_ _7354_/CLK _7186_/D _6466_/Y VGND VGND VPWR VPWR _7186_/Q sky130_fd_sc_hd__dfrtp_2
X_4398_ _7338_/Q _3954_/S _4419_/A2 _7306_/Q VGND VGND VPWR VPWR _4398_/X sky130_fd_sc_hd__a22o_2
X_3418_ _7283_/Q _5142_/S _3417_/X _7091_/Q VGND VGND VPWR VPWR _3418_/X sky130_fd_sc_hd__a22o_2
XFILLER_58_502 VGND VGND VPWR VPWR sky130_fd_sc_hd__decap_3
XFILLER_98_693 VGND VGND VPWR VPWR sky130_fd_sc_hd__decap_3
Xhold1000 _7062_/Q VGND VGND VPWR VPWR _7062_/D sky130_fd_sc_hd__dlygate4sd3_1
X_3349_ _5129_/A _5294_/A VGND VGND VPWR VPWR _3350_/B sky130_fd_sc_hd__nand2_2
XTAP_TAPCELL_ROW_5_325 VGND VPWR sky130_fd_sc_hd__tapvpwrvgnd_1
XFILLER_100_632 VGND VGND VPWR VPWR sky130_fd_sc_hd__decap_3
XFILLER_100_654 VGND VGND VPWR VPWR sky130_fd_sc_hd__decap_3
XFILLER_97_192 VGND VGND VPWR VPWR sky130_fd_sc_hd__decap_3
Xhold1011 _6705_/Q VGND VGND VPWR VPWR _5710_/A1 sky130_fd_sc_hd__dlygate4sd3_1
Xhold1022 _6715_/Q VGND VGND VPWR VPWR _5731_/A1 sky130_fd_sc_hd__dlygate4sd3_1
Xhold1033 _6711_/Q VGND VGND VPWR VPWR _5723_/A1 sky130_fd_sc_hd__dlygate4sd3_1
XFILLER_100_687 VGND VGND VPWR VPWR sky130_fd_sc_hd__decap_3
XFILLER_45_218 VGND VGND VPWR VPWR sky130_fd_sc_hd__decap_3
XFILLER_73_505 VGND VGND VPWR VPWR sky130_fd_sc_hd__decap_3
XFILLER_85_376 VGND VGND VPWR VPWR sky130_fd_sc_hd__decap_3
Xhold1044 _7048_/Q VGND VGND VPWR VPWR _5569_/A1 sky130_fd_sc_hd__dlygate4sd3_1
Xhold1055 _7054_/Q VGND VGND VPWR VPWR _5561_/A1 sky130_fd_sc_hd__dlygate4sd3_1
Xhold1066 _7279_/Q VGND VGND VPWR VPWR _4603_/A1 sky130_fd_sc_hd__dlygate4sd3_1
XFILLER_26_421 VGND VGND VPWR VPWR sky130_fd_sc_hd__fill_2
Xhold1077 _7184_/Q VGND VGND VPWR VPWR _5290_/A0 sky130_fd_sc_hd__dlygate4sd3_1
Xhold1088 _7191_/Q VGND VGND VPWR VPWR _5278_/A0 sky130_fd_sc_hd__dlygate4sd3_1
Xhold1099 _7204_/Q VGND VGND VPWR VPWR _5251_/A0 sky130_fd_sc_hd__dlygate4sd3_1
X_5019_ _4243_/Y _5032_/B _4989_/X _5018_/Y VGND VGND VPWR VPWR _5020_/B sky130_fd_sc_hd__a22o_2
XFILLER_26_56 VGND VGND VPWR VPWR sky130_fd_sc_hd__decap_3
XFILLER_14_616 VGND VGND VPWR VPWR sky130_fd_sc_hd__decap_3
XFILLER_26_498 VGND VGND VPWR VPWR sky130_fd_sc_hd__decap_3
XFILLER_26_78 VGND VGND VPWR VPWR sky130_fd_sc_hd__decap_3
XFILLER_41_424 VGND VGND VPWR VPWR sky130_fd_sc_hd__fill_2
XFILLER_53_284 VGND VGND VPWR VPWR sky130_fd_sc_hd__decap_3
XFILLER_13_159 VGND VGND VPWR VPWR sky130_fd_sc_hd__fill_1
XFILLER_22_660 VGND VGND VPWR VPWR sky130_fd_sc_hd__decap_3
XFILLER_42_33 VGND VGND VPWR VPWR sky130_fd_sc_hd__fill_2
XFILLER_22_693 VGND VGND VPWR VPWR sky130_fd_sc_hd__decap_3
XFILLER_108_710 VGND VGND VPWR VPWR sky130_fd_sc_hd__decap_3
XFILLER_5_314 VGND VGND VPWR VPWR sky130_fd_sc_hd__decap_3
XFILLER_5_358 VGND VGND VPWR VPWR sky130_fd_sc_hd__decap_3
XFILLER_1_520 VGND VGND VPWR VPWR sky130_fd_sc_hd__decap_3
XFILLER_1_553 VGND VGND VPWR VPWR sky130_fd_sc_hd__decap_3
XFILLER_96_619 VGND VGND VPWR VPWR sky130_fd_sc_hd__decap_3
XFILLER_107_81 VGND VGND VPWR VPWR sky130_fd_sc_hd__decap_3
XFILLER_1_564 VGND VGND VPWR VPWR sky130_fd_sc_hd__decap_3
XFILLER_67_41 VGND VGND VPWR VPWR sky130_fd_sc_hd__decap_3
XFILLER_89_671 VGND VGND VPWR VPWR sky130_fd_sc_hd__fill_1
XFILLER_89_682 VGND VGND VPWR VPWR sky130_fd_sc_hd__decap_3
XFILLER_103_481 VGND VGND VPWR VPWR sky130_fd_sc_hd__fill_2
XFILLER_1_597 VGND VGND VPWR VPWR sky130_fd_sc_hd__decap_3
XFILLER_76_332 VGND VGND VPWR VPWR sky130_fd_sc_hd__decap_3
XFILLER_88_192 VGND VGND VPWR VPWR sky130_fd_sc_hd__decap_3
XFILLER_76_354 VGND VGND VPWR VPWR sky130_fd_sc_hd__decap_3
XFILLER_76_365 VGND VGND VPWR VPWR sky130_fd_sc_hd__decap_3
XTAP_TAPCELL_ROW_108_1609 VGND VPWR sky130_fd_sc_hd__tapvpwrvgnd_1
XFILLER_17_421 VGND VGND VPWR VPWR sky130_fd_sc_hd__decap_3
XFILLER_29_270 VGND VGND VPWR VPWR sky130_fd_sc_hd__decap_3
XFILLER_29_281 VGND VGND VPWR VPWR sky130_fd_sc_hd__decap_3
XFILLER_36_218 VGND VGND VPWR VPWR sky130_fd_sc_hd__decap_3
XFILLER_91_324 VGND VGND VPWR VPWR sky130_fd_sc_hd__decap_3
XFILLER_44_240 VGND VGND VPWR VPWR sky130_fd_sc_hd__decap_3
XFILLER_91_357 VGND VGND VPWR VPWR sky130_fd_sc_hd__decap_3
XFILLER_17_465 VGND VGND VPWR VPWR sky130_fd_sc_hd__decap_3
XFILLER_32_424 VGND VGND VPWR VPWR sky130_fd_sc_hd__decap_3
XFILLER_44_273 VGND VGND VPWR VPWR sky130_fd_sc_hd__fill_2
XFILLER_83_84 VGND VGND VPWR VPWR sky130_fd_sc_hd__decap_3
XFILLER_32_457 VGND VGND VPWR VPWR sky130_fd_sc_hd__decap_3
XTAP_TAPCELL_ROW_67_1096 VGND VPWR sky130_fd_sc_hd__tapvpwrvgnd_1
XFILLER_13_671 VGND VGND VPWR VPWR sky130_fd_sc_hd__fill_1
XFILLER_20_619 VGND VGND VPWR VPWR sky130_fd_sc_hd__decap_3
XTAP_TAPCELL_ROW_80_1263 VGND VPWR sky130_fd_sc_hd__tapvpwrvgnd_1
XTAP_TAPCELL_ROW_80_1252 VGND VPWR sky130_fd_sc_hd__tapvpwrvgnd_1
XFILLER_9_620 VGND VGND VPWR VPWR sky130_fd_sc_hd__decap_3
XFILLER_13_682 VGND VGND VPWR VPWR sky130_fd_sc_hd__decap_3
XFILLER_80_6 VGND VGND VPWR VPWR sky130_fd_sc_hd__decap_3
XTAP_TAPCELL_ROW_30_636 VGND VPWR sky130_fd_sc_hd__tapvpwrvgnd_1
XFILLER_9_653 VGND VGND VPWR VPWR sky130_fd_sc_hd__decap_3
XFILLER_8_141 VGND VGND VPWR VPWR sky130_fd_sc_hd__decap_3
XTAP_TAPCELL_ROW_119_1749 VGND VPWR sky130_fd_sc_hd__tapvpwrvgnd_1
XFILLER_9_697 VGND VGND VPWR VPWR sky130_fd_sc_hd__decap_3
XFILLER_114_713 VGND VGND VPWR VPWR sky130_fd_sc_hd__fill_1
XTAP_TAPCELL_ROW_10_382 VGND VPWR sky130_fd_sc_hd__tapvpwrvgnd_1
X_4321_ _7098_/Q _4351_/A2 _4333_/A2 _7130_/Q VGND VGND VPWR VPWR _4321_/X sky130_fd_sc_hd__a22o_2
XFILLER_99_424 VGND VGND VPWR VPWR sky130_fd_sc_hd__decap_3
XFILLER_113_234 VGND VGND VPWR VPWR sky130_fd_sc_hd__decap_3
X_7040_ _7387_/CLK _7040_/D _6320_/Y VGND VGND VPWR VPWR _7040_/Q sky130_fd_sc_hd__dfrtp_2
X_4252_ _7197_/Q _3966_/S _4272_/B _7357_/Q VGND VGND VPWR VPWR _4252_/X sky130_fd_sc_hd__a22o_2
XFILLER_101_418 VGND VGND VPWR VPWR sky130_fd_sc_hd__decap_3
XFILLER_113_278 VGND VGND VPWR VPWR sky130_fd_sc_hd__fill_2
XFILLER_86_129 VGND VGND VPWR VPWR sky130_fd_sc_hd__decap_3
XTAP_TAPCELL_ROW_91_1392 VGND VPWR sky130_fd_sc_hd__tapvpwrvgnd_1
XFILLER_67_321 VGND VGND VPWR VPWR sky130_fd_sc_hd__fill_2
XFILLER_67_332 VGND VGND VPWR VPWR sky130_fd_sc_hd__decap_3
XFILLER_67_343 VGND VGND VPWR VPWR sky130_fd_sc_hd__fill_2
XFILLER_79_181 VGND VGND VPWR VPWR sky130_fd_sc_hd__decap_3
XFILLER_95_641 VGND VGND VPWR VPWR sky130_fd_sc_hd__decap_3
X_4183_ _7360_/Q _4416_/A2 _4267_/B1 _7168_/Q _4182_/X VGND VGND VPWR VPWR _4183_/X
+ sky130_fd_sc_hd__a221o_2
XFILLER_27_207 VGND VGND VPWR VPWR sky130_fd_sc_hd__decap_3
XFILLER_67_354 VGND VGND VPWR VPWR sky130_fd_sc_hd__decap_3
XFILLER_95_685 VGND VGND VPWR VPWR sky130_fd_sc_hd__decap_3
XFILLER_94_173 VGND VGND VPWR VPWR sky130_fd_sc_hd__fill_1
XTAP_TAPCELL_ROW_38_736 VGND VPWR sky130_fd_sc_hd__tapvpwrvgnd_1
XFILLER_35_240 VGND VGND VPWR VPWR sky130_fd_sc_hd__fill_1
XFILLER_82_368 VGND VGND VPWR VPWR sky130_fd_sc_hd__decap_3
XFILLER_35_262 VGND VGND VPWR VPWR sky130_fd_sc_hd__fill_1
XFILLER_51_700 VGND VGND VPWR VPWR sky130_fd_sc_hd__decap_3
XFILLER_35_284 VGND VGND VPWR VPWR sky130_fd_sc_hd__decap_3
XFILLER_50_221 VGND VGND VPWR VPWR sky130_fd_sc_hd__decap_3
Xplace560 _6463_/A VGND VGND VPWR VPWR _6662_/A sky130_fd_sc_hd__buf_2
Xplace571 place571/A VGND VGND VPWR VPWR _6632_/A sky130_fd_sc_hd__buf_2
X_6824_ clkload8/A _6824_/D VGND VGND VPWR VPWR _6824_/Q sky130_fd_sc_hd__dfxtp_2
XTAP_TAPCELL_ROW_18_482 VGND VPWR sky130_fd_sc_hd__tapvpwrvgnd_1
XFILLER_50_265 VGND VGND VPWR VPWR sky130_fd_sc_hd__decap_3
X_6755_ clkload4/A _6755_/D VGND VGND VPWR VPWR _6755_/Q sky130_fd_sc_hd__dfxtp_2
X_5706_ _7359_/Q _6703_/Q _5708_/S VGND VGND VPWR VPWR _6703_/D sky130_fd_sc_hd__mux2_2
XFILLER_109_518 VGND VGND VPWR VPWR sky130_fd_sc_hd__fill_2
Xclkbuf_leaf_30_clk clkload0/A VGND VGND VPWR VPWR _7322_/CLK sky130_fd_sc_hd__clkbuf_16
X_6686_ _6686_/A VGND VGND VPWR VPWR _6686_/Y sky130_fd_sc_hd__inv_2
X_3898_ _6919_/Q _3926_/A2 _3926_/B1 _6783_/Q VGND VGND VPWR VPWR _3898_/X sky130_fd_sc_hd__a22o_2
X_5568_ _5568_/A1 _4960_/A _4897_/X VGND VGND VPWR VPWR _7049_/D sky130_fd_sc_hd__a21o_2
X_7307_ _7371_/CLK _7307_/D _6587_/Y VGND VGND VPWR VPWR _7307_/Q sky130_fd_sc_hd__dfrtp_2
X_4519_ _4519_/A1 _3398_/Y _4300_/X VGND VGND VPWR VPWR _7320_/D sky130_fd_sc_hd__a21o_2
XFILLER_104_245 VGND VGND VPWR VPWR sky130_fd_sc_hd__decap_3
XFILLER_104_256 VGND VGND VPWR VPWR sky130_fd_sc_hd__decap_3
X_7238_ _7342_/CLK _7238_/D _6518_/Y VGND VGND VPWR VPWR _7238_/Q sky130_fd_sc_hd__dfrtp_2
XFILLER_86_641 VGND VGND VPWR VPWR sky130_fd_sc_hd__decap_3
X_7169_ _7362_/CLK _7169_/D _6449_/Y VGND VGND VPWR VPWR _7169_/Q sky130_fd_sc_hd__dfrtp_2
XFILLER_100_440 VGND VGND VPWR VPWR sky130_fd_sc_hd__decap_3
XFILLER_58_365 VGND VGND VPWR VPWR sky130_fd_sc_hd__decap_3
XFILLER_85_140 VGND VGND VPWR VPWR sky130_fd_sc_hd__decap_3
XFILLER_86_663 VGND VGND VPWR VPWR sky130_fd_sc_hd__decap_3
XFILLER_37_55 VGND VGND VPWR VPWR sky130_fd_sc_hd__fill_1
XFILLER_85_195 VGND VGND VPWR VPWR sky130_fd_sc_hd__decap_3
XFILLER_86_696 VGND VGND VPWR VPWR sky130_fd_sc_hd__decap_3
XFILLER_37_99 VGND VGND VPWR VPWR sky130_fd_sc_hd__decap_3
XFILLER_73_357 VGND VGND VPWR VPWR sky130_fd_sc_hd__fill_1
XFILLER_54_560 VGND VGND VPWR VPWR sky130_fd_sc_hd__fill_2
XFILLER_14_424 VGND VGND VPWR VPWR sky130_fd_sc_hd__decap_3
XFILLER_26_284 VGND VGND VPWR VPWR sky130_fd_sc_hd__decap_3
XFILLER_53_43 VGND VGND VPWR VPWR sky130_fd_sc_hd__decap_3
XFILLER_14_457 VGND VGND VPWR VPWR sky130_fd_sc_hd__decap_3
XFILLER_41_287 VGND VGND VPWR VPWR sky130_fd_sc_hd__fill_2
XFILLER_53_98 VGND VGND VPWR VPWR sky130_fd_sc_hd__decap_3
XFILLER_10_663 VGND VGND VPWR VPWR sky130_fd_sc_hd__decap_3
XFILLER_6_601 VGND VGND VPWR VPWR sky130_fd_sc_hd__decap_3
Xclkbuf_leaf_21_clk clkload2/A VGND VGND VPWR VPWR _7373_/CLK sky130_fd_sc_hd__clkbuf_16
XFILLER_10_696 VGND VGND VPWR VPWR sky130_fd_sc_hd__decap_3
XFILLER_6_634 VGND VGND VPWR VPWR sky130_fd_sc_hd__decap_3
XFILLER_6_645 VGND VGND VPWR VPWR sky130_fd_sc_hd__decap_3
XFILLER_6_678 VGND VGND VPWR VPWR sky130_fd_sc_hd__decap_3
XFILLER_108_584 VGND VGND VPWR VPWR sky130_fd_sc_hd__decap_3
XFILLER_108_595 VGND VGND VPWR VPWR sky130_fd_sc_hd__decap_3
XFILLER_118_80 VGND VGND VPWR VPWR sky130_fd_sc_hd__decap_3
XFILLER_118_91 VGND VGND VPWR VPWR sky130_fd_sc_hd__decap_3
XTAP_TAPCELL_ROW_114_1679 VGND VPWR sky130_fd_sc_hd__tapvpwrvgnd_1
XFILLER_1_361 VGND VGND VPWR VPWR sky130_fd_sc_hd__fill_1
XFILLER_78_62 VGND VGND VPWR VPWR sky130_fd_sc_hd__decap_3
XFILLER_77_641 VGND VGND VPWR VPWR sky130_fd_sc_hd__decap_3
XFILLER_96_438 VGND VGND VPWR VPWR sky130_fd_sc_hd__decap_3
XFILLER_110_259 VGND VGND VPWR VPWR sky130_fd_sc_hd__decap_3
XFILLER_37_505 VGND VGND VPWR VPWR sky130_fd_sc_hd__decap_3
XFILLER_49_376 VGND VGND VPWR VPWR sky130_fd_sc_hd__decap_3
XFILLER_49_387 VGND VGND VPWR VPWR sky130_fd_sc_hd__decap_3
XFILLER_77_685 VGND VGND VPWR VPWR sky130_fd_sc_hd__decap_3
XFILLER_92_622 VGND VGND VPWR VPWR sky130_fd_sc_hd__decap_3
XFILLER_94_72 VGND VGND VPWR VPWR sky130_fd_sc_hd__decap_3
XTAP_TAPCELL_ROW_69_1125 VGND VPWR sky130_fd_sc_hd__tapvpwrvgnd_1
XFILLER_64_368 VGND VGND VPWR VPWR sky130_fd_sc_hd__decap_3
XFILLER_76_195 VGND VGND VPWR VPWR sky130_fd_sc_hd__fill_1
XFILLER_91_154 VGND VGND VPWR VPWR sky130_fd_sc_hd__decap_3
XFILLER_92_666 VGND VGND VPWR VPWR sky130_fd_sc_hd__decap_3
XFILLER_94_94 VGND VGND VPWR VPWR sky130_fd_sc_hd__decap_3
XFILLER_33_700 VGND VGND VPWR VPWR sky130_fd_sc_hd__decap_3
XFILLER_91_187 VGND VGND VPWR VPWR sky130_fd_sc_hd__decap_3
XFILLER_92_699 VGND VGND VPWR VPWR sky130_fd_sc_hd__fill_1
XFILLER_17_284 VGND VGND VPWR VPWR sky130_fd_sc_hd__decap_3
XFILLER_45_593 VGND VGND VPWR VPWR sky130_fd_sc_hd__decap_3
XFILLER_60_530 VGND VGND VPWR VPWR sky130_fd_sc_hd__fill_2
X_4870_ _4870_/A _4870_/B VGND VGND VPWR VPWR _4870_/Y sky130_fd_sc_hd__nor2_2
XFILLER_32_243 VGND VGND VPWR VPWR sky130_fd_sc_hd__decap_3
X_3821_ _3746_/C _3819_/X _3820_/X _4770_/A1 VGND VGND VPWR VPWR _5010_/C sky130_fd_sc_hd__o31a_2
XTAP_TAPCELL_ROW_15_441 VGND VPWR sky130_fd_sc_hd__tapvpwrvgnd_1
XFILLER_60_585 VGND VGND VPWR VPWR sky130_fd_sc_hd__decap_3
X_6540_ _6544_/A VGND VGND VPWR VPWR _6540_/Y sky130_fd_sc_hd__inv_2
XTAP_TAPCELL_ROW_43_794 VGND VPWR sky130_fd_sc_hd__tapvpwrvgnd_1
Xclkbuf_leaf_12_clk clkload1/A VGND VGND VPWR VPWR _7086_/CLK sky130_fd_sc_hd__clkbuf_16
X_3752_ _6799_/Q _3759_/A2 _3760_/B1 _6709_/Q _3751_/X VGND VGND VPWR VPWR _3752_/X
+ sky130_fd_sc_hd__a221o_2
XFILLER_9_461 VGND VGND VPWR VPWR sky130_fd_sc_hd__decap_3
X_6471_ _6535_/A VGND VGND VPWR VPWR _6471_/Y sky130_fd_sc_hd__inv_2
X_3683_ _3672_/X _3673_/X _4770_/A1 _3682_/Y VGND VGND VPWR VPWR _3683_/Y sky130_fd_sc_hd__o211ai_2
XFILLER_114_521 VGND VGND VPWR VPWR sky130_fd_sc_hd__decap_3
XTAP_TAPCELL_ROW_93_1421 VGND VPWR sky130_fd_sc_hd__tapvpwrvgnd_1
XFILLER_99_210 VGND VGND VPWR VPWR sky130_fd_sc_hd__fill_2
X_4304_ _7256_/Q _4601_/S _4303_/X VGND VGND VPWR VPWR _4364_/A sky130_fd_sc_hd__a21oi_2
XFILLER_99_254 VGND VGND VPWR VPWR sky130_fd_sc_hd__decap_3
XFILLER_114_576 VGND VGND VPWR VPWR sky130_fd_sc_hd__decap_3
X_5284_ _5284_/A0 _5135_/X _5292_/S VGND VGND VPWR VPWR _7187_/D sky130_fd_sc_hd__mux2_2
XFILLER_99_276 VGND VGND VPWR VPWR sky130_fd_sc_hd__decap_3
XFILLER_101_215 VGND VGND VPWR VPWR sky130_fd_sc_hd__decap_3
XFILLER_114_598 VGND VGND VPWR VPWR sky130_fd_sc_hd__decap_3
XFILLER_68_630 VGND VGND VPWR VPWR sky130_fd_sc_hd__decap_3
XFILLER_87_449 VGND VGND VPWR VPWR sky130_fd_sc_hd__decap_3
X_7023_ _7342_/CLK _7023_/D _6303_/Y VGND VGND VPWR VPWR _7023_/Q sky130_fd_sc_hd__dfrtp_2
X_4235_ _7227_/Q _4349_/B1 _4348_/B1 _7131_/Q VGND VGND VPWR VPWR _4235_/X sky130_fd_sc_hd__a22o_2
XFILLER_101_259 VGND VGND VPWR VPWR sky130_fd_sc_hd__fill_2
XFILLER_114_38 VGND VGND VPWR VPWR sky130_fd_sc_hd__decap_3
XFILLER_28_505 VGND VGND VPWR VPWR sky130_fd_sc_hd__decap_3
XFILLER_68_663 VGND VGND VPWR VPWR sky130_fd_sc_hd__decap_3
X_4166_ _7233_/Q _4353_/A2 _3947_/S _7201_/Q VGND VGND VPWR VPWR _4166_/X sky130_fd_sc_hd__a22o_2
XFILLER_68_696 VGND VGND VPWR VPWR sky130_fd_sc_hd__decap_3
XFILLER_83_611 VGND VGND VPWR VPWR sky130_fd_sc_hd__decap_3
XFILLER_43_508 VGND VGND VPWR VPWR sky130_fd_sc_hd__decap_3
XFILLER_55_346 VGND VGND VPWR VPWR sky130_fd_sc_hd__decap_3
XFILLER_67_195 VGND VGND VPWR VPWR sky130_fd_sc_hd__decap_3
XFILLER_82_121 VGND VGND VPWR VPWR sky130_fd_sc_hd__decap_3
XFILLER_83_644 VGND VGND VPWR VPWR sky130_fd_sc_hd__decap_3
XFILLER_70_305 VGND VGND VPWR VPWR sky130_fd_sc_hd__decap_3
XFILLER_83_688 VGND VGND VPWR VPWR sky130_fd_sc_hd__decap_3
XFILLER_23_221 VGND VGND VPWR VPWR sky130_fd_sc_hd__decap_3
XFILLER_63_390 VGND VGND VPWR VPWR sky130_fd_sc_hd__fill_2
XFILLER_23_254 VGND VGND VPWR VPWR sky130_fd_sc_hd__fill_2
Xplace390 _4421_/A2 VGND VGND VPWR VPWR _4430_/A2 sky130_fd_sc_hd__buf_2
X_6807_ _6941_/CLK _6807_/D VGND VGND VPWR VPWR _6807_/Q sky130_fd_sc_hd__dfxtp_2
XFILLER_11_449 VGND VGND VPWR VPWR sky130_fd_sc_hd__fill_1
X_6738_ clkload7/A _6738_/D VGND VGND VPWR VPWR _6738_/Q sky130_fd_sc_hd__dfxtp_2
XFILLER_109_315 VGND VGND VPWR VPWR sky130_fd_sc_hd__decap_3
XFILLER_109_337 VGND VGND VPWR VPWR sky130_fd_sc_hd__decap_3
X_6669_ _6671_/A VGND VGND VPWR VPWR _6669_/Y sky130_fd_sc_hd__inv_2
XFILLER_105_521 VGND VGND VPWR VPWR sky130_fd_sc_hd__decap_3
XFILLER_3_604 VGND VGND VPWR VPWR sky130_fd_sc_hd__decap_3
XFILLER_3_626 VGND VGND VPWR VPWR sky130_fd_sc_hd__decap_3
XFILLER_105_543 VGND VGND VPWR VPWR sky130_fd_sc_hd__fill_2
XFILLER_105_554 VGND VGND VPWR VPWR sky130_fd_sc_hd__fill_1
XFILLER_2_125 VGND VGND VPWR VPWR sky130_fd_sc_hd__decap_3
XFILLER_2_136 VGND VGND VPWR VPWR sky130_fd_sc_hd__decap_3
XFILLER_3_659 VGND VGND VPWR VPWR sky130_fd_sc_hd__decap_3
XFILLER_78_405 VGND VGND VPWR VPWR sky130_fd_sc_hd__decap_3
XFILLER_78_427 VGND VGND VPWR VPWR sky130_fd_sc_hd__decap_3
XFILLER_59_641 VGND VGND VPWR VPWR sky130_fd_sc_hd__decap_3
XFILLER_19_505 VGND VGND VPWR VPWR sky130_fd_sc_hd__decap_3
XFILLER_86_460 VGND VGND VPWR VPWR sky130_fd_sc_hd__decap_3
XFILLER_58_162 VGND VGND VPWR VPWR sky130_fd_sc_hd__decap_3
XFILLER_58_184 VGND VGND VPWR VPWR sky130_fd_sc_hd__decap_3
XFILLER_59_685 VGND VGND VPWR VPWR sky130_fd_sc_hd__decap_3
XFILLER_73_110 VGND VGND VPWR VPWR sky130_fd_sc_hd__fill_2
XFILLER_74_633 VGND VGND VPWR VPWR sky130_fd_sc_hd__decap_3
XFILLER_34_508 VGND VGND VPWR VPWR sky130_fd_sc_hd__decap_3
XFILLER_74_666 VGND VGND VPWR VPWR sky130_fd_sc_hd__decap_3
XFILLER_15_700 VGND VGND VPWR VPWR sky130_fd_sc_hd__decap_3
XFILLER_46_379 VGND VGND VPWR VPWR sky130_fd_sc_hd__decap_3
XFILLER_74_699 VGND VGND VPWR VPWR sky130_fd_sc_hd__fill_1
XFILLER_27_582 VGND VGND VPWR VPWR sky130_fd_sc_hd__decap_3
XFILLER_42_530 VGND VGND VPWR VPWR sky130_fd_sc_hd__fill_2
XFILLER_54_390 VGND VGND VPWR VPWR sky130_fd_sc_hd__decap_3
XFILLER_73_187 VGND VGND VPWR VPWR sky130_fd_sc_hd__fill_2
XFILLER_14_265 VGND VGND VPWR VPWR sky130_fd_sc_hd__decap_3
XTAP_TAPCELL_ROW_64_1055 VGND VPWR sky130_fd_sc_hd__tapvpwrvgnd_1
XTAP_TAPCELL_ROW_12_411 VGND VPWR sky130_fd_sc_hd__tapvpwrvgnd_1
XFILLER_9_48 VGND VGND VPWR VPWR sky130_fd_sc_hd__decap_3
XTAP_TAPCELL_ROW_40_753 VGND VPWR sky130_fd_sc_hd__tapvpwrvgnd_1
XFILLER_80_85 VGND VGND VPWR VPWR sky130_fd_sc_hd__decap_3
XTAP_TAPCELL_ROW_40_764 VGND VPWR sky130_fd_sc_hd__tapvpwrvgnd_1
XTAP_TAPCELL_ROW_116_1708 VGND VPWR sky130_fd_sc_hd__tapvpwrvgnd_1
XFILLER_115_318 VGND VGND VPWR VPWR sky130_fd_sc_hd__decap_3
XFILLER_108_392 VGND VGND VPWR VPWR sky130_fd_sc_hd__decap_3
XFILLER_89_94 VGND VGND VPWR VPWR sky130_fd_sc_hd__decap_3
XFILLER_97_703 VGND VGND VPWR VPWR sky130_fd_sc_hd__decap_3
XTAP_TAPCELL_ROW_75_1195 VGND VPWR sky130_fd_sc_hd__tapvpwrvgnd_1
XFILLER_2_681 VGND VGND VPWR VPWR sky130_fd_sc_hd__decap_3
XFILLER_96_213 VGND VGND VPWR VPWR sky130_fd_sc_hd__fill_2
XFILLER_111_579 VGND VGND VPWR VPWR sky130_fd_sc_hd__decap_3
XFILLER_65_600 VGND VGND VPWR VPWR sky130_fd_sc_hd__decap_3
XFILLER_84_408 VGND VGND VPWR VPWR sky130_fd_sc_hd__decap_3
XFILLER_84_419 VGND VGND VPWR VPWR sky130_fd_sc_hd__fill_1
Xclkbuf_leaf_1_clk clkbuf_leaf_1_clk/A VGND VGND VPWR VPWR clkload3/A sky130_fd_sc_hd__clkbuf_16
X_4020_ _7086_/Q _4102_/B _4432_/B1 _4019_/X VGND VGND VPWR VPWR _4039_/A sky130_fd_sc_hd__o211ai_2
XFILLER_37_313 VGND VGND VPWR VPWR sky130_fd_sc_hd__decap_3
XFILLER_49_151 VGND VGND VPWR VPWR sky130_fd_sc_hd__fill_1
XFILLER_49_162 VGND VGND VPWR VPWR sky130_fd_sc_hd__decap_3
XFILLER_64_110 VGND VGND VPWR VPWR sky130_fd_sc_hd__decap_3
XFILLER_77_482 VGND VGND VPWR VPWR sky130_fd_sc_hd__decap_3
XFILLER_37_346 VGND VGND VPWR VPWR sky130_fd_sc_hd__decap_3
XFILLER_49_195 VGND VGND VPWR VPWR sky130_fd_sc_hd__decap_3
XFILLER_64_132 VGND VGND VPWR VPWR sky130_fd_sc_hd__decap_3
XFILLER_65_644 VGND VGND VPWR VPWR sky130_fd_sc_hd__decap_3
XFILLER_92_441 VGND VGND VPWR VPWR sky130_fd_sc_hd__decap_3
XTAP_TAPCELL_ROW_48_853 VGND VPWR sky130_fd_sc_hd__tapvpwrvgnd_1
XFILLER_25_508 VGND VGND VPWR VPWR sky130_fd_sc_hd__fill_2
XFILLER_25_519 VGND VGND VPWR VPWR sky130_fd_sc_hd__fill_1
XFILLER_64_165 VGND VGND VPWR VPWR sky130_fd_sc_hd__decap_3
XFILLER_65_688 VGND VGND VPWR VPWR sky130_fd_sc_hd__decap_3
XTAP_TAPCELL_ROW_48_864 VGND VPWR sky130_fd_sc_hd__tapvpwrvgnd_1
XFILLER_45_390 VGND VGND VPWR VPWR sky130_fd_sc_hd__fill_2
XFILLER_80_636 VGND VGND VPWR VPWR sky130_fd_sc_hd__decap_3
XFILLER_80_669 VGND VGND VPWR VPWR sky130_fd_sc_hd__decap_3
X_4922_ _4937_/A _4937_/B _4203_/X VGND VGND VPWR VPWR _4922_/X sky130_fd_sc_hd__a21o_2
XFILLER_21_703 VGND VGND VPWR VPWR sky130_fd_sc_hd__decap_3
XFILLER_33_585 VGND VGND VPWR VPWR sky130_fd_sc_hd__decap_3
XFILLER_60_360 VGND VGND VPWR VPWR sky130_fd_sc_hd__decap_3
X_4784_ _4813_/A _4829_/B VGND VGND VPWR VPWR _4811_/B sky130_fd_sc_hd__nand2_2
X_3804_ _6826_/Q _3906_/A2 _3889_/B1 _6811_/Q _3803_/X VGND VGND VPWR VPWR _3804_/X
+ sky130_fd_sc_hd__a221o_2
X_6523_ _6556_/A VGND VGND VPWR VPWR _6523_/Y sky130_fd_sc_hd__inv_2
X_3735_ _3735_/A _3746_/B _3746_/C VGND VGND VPWR VPWR _3735_/X sky130_fd_sc_hd__and3_4
XFILLER_109_27 VGND VGND VPWR VPWR sky130_fd_sc_hd__decap_3
XFILLER_118_134 VGND VGND VPWR VPWR sky130_fd_sc_hd__fill_1
XFILLER_119_657 VGND VGND VPWR VPWR sky130_fd_sc_hd__fill_1
XFILLER_119_679 VGND VGND VPWR VPWR sky130_fd_sc_hd__decap_3
X_6454_ _6648_/A VGND VGND VPWR VPWR _6454_/Y sky130_fd_sc_hd__inv_2
XFILLER_106_307 VGND VGND VPWR VPWR sky130_fd_sc_hd__fill_1
XFILLER_106_318 VGND VGND VPWR VPWR sky130_fd_sc_hd__decap_3
XFILLER_118_189 VGND VGND VPWR VPWR sky130_fd_sc_hd__decap_3
X_6385_ _6610_/A VGND VGND VPWR VPWR _6385_/Y sky130_fd_sc_hd__inv_2
X_3597_ _4295_/B _3607_/B VGND VGND VPWR VPWR _3611_/B sky130_fd_sc_hd__nor2_2
XFILLER_0_629 VGND VGND VPWR VPWR sky130_fd_sc_hd__decap_3
XFILLER_102_513 VGND VGND VPWR VPWR sky130_fd_sc_hd__decap_3
XFILLER_87_202 VGND VGND VPWR VPWR sky130_fd_sc_hd__decap_3
X_5336_ _5336_/A0 _5040_/X _7412_/A VGND VGND VPWR VPWR _7163_/D sky130_fd_sc_hd__mux2_2
XPHY_EDGE_ROW_10_Left_130 VGND VGND VPWR VPWR sky130_fd_sc_hd__decap_3
XFILLER_75_408 VGND VGND VPWR VPWR sky130_fd_sc_hd__decap_3
XFILLER_87_246 VGND VGND VPWR VPWR sky130_fd_sc_hd__decap_3
X_7006_ _7373_/CLK _7006_/D _6286_/Y VGND VGND VPWR VPWR _7006_/Q sky130_fd_sc_hd__dfrtp_2
X_4218_ _7100_/Q _4351_/A2 _4351_/B1 _7132_/Q VGND VGND VPWR VPWR _4218_/X sky130_fd_sc_hd__a22o_2
XFILLER_28_302 VGND VGND VPWR VPWR sky130_fd_sc_hd__decap_3
XFILLER_56_622 VGND VGND VPWR VPWR sky130_fd_sc_hd__decap_3
X_5198_ _5198_/A _5198_/B VGND VGND VPWR VPWR _7229_/D sky130_fd_sc_hd__and2_2
XFILLER_56_666 VGND VGND VPWR VPWR sky130_fd_sc_hd__decap_3
XFILLER_83_452 VGND VGND VPWR VPWR sky130_fd_sc_hd__decap_3
X_4149_ _4205_/A _4205_/B VGND VGND VPWR VPWR _4157_/A sky130_fd_sc_hd__nand2_2
XFILLER_28_368 VGND VGND VPWR VPWR sky130_fd_sc_hd__fill_2
XFILLER_43_305 VGND VGND VPWR VPWR sky130_fd_sc_hd__decap_3
XFILLER_55_165 VGND VGND VPWR VPWR sky130_fd_sc_hd__decap_3
XFILLER_56_699 VGND VGND VPWR VPWR sky130_fd_sc_hd__fill_1
XFILLER_83_463 VGND VGND VPWR VPWR sky130_fd_sc_hd__fill_2
XFILLER_83_485 VGND VGND VPWR VPWR sky130_fd_sc_hd__decap_3
XFILLER_71_647 VGND VGND VPWR VPWR sky130_fd_sc_hd__decap_3
XFILLER_70_168 VGND VGND VPWR VPWR sky130_fd_sc_hd__decap_3
XFILLER_11_202 VGND VGND VPWR VPWR sky130_fd_sc_hd__fill_2
XFILLER_34_67 VGND VGND VPWR VPWR sky130_fd_sc_hd__fill_1
XTAP_TAPCELL_ROW_100_1509 VGND VPWR sky130_fd_sc_hd__tapvpwrvgnd_1
XFILLER_51_393 VGND VGND VPWR VPWR sky130_fd_sc_hd__decap_3
XFILLER_8_707 VGND VGND VPWR VPWR sky130_fd_sc_hd__decap_3
XFILLER_11_279 VGND VGND VPWR VPWR sky130_fd_sc_hd__fill_1
XFILLER_50_11 VGND VGND VPWR VPWR sky130_fd_sc_hd__fill_1
Xclkload0 clkload0/A VGND VGND VPWR VPWR clkload0/X sky130_fd_sc_hd__clkbuf_16
XFILLER_109_134 VGND VGND VPWR VPWR sky130_fd_sc_hd__decap_3
XFILLER_109_178 VGND VGND VPWR VPWR sky130_fd_sc_hd__decap_3
XFILLER_50_88 VGND VGND VPWR VPWR sky130_fd_sc_hd__decap_3
XFILLER_118_690 VGND VGND VPWR VPWR sky130_fd_sc_hd__decap_3
XFILLER_3_423 VGND VGND VPWR VPWR sky130_fd_sc_hd__decap_3
XFILLER_105_340 VGND VGND VPWR VPWR sky130_fd_sc_hd__decap_3
XFILLER_79_703 VGND VGND VPWR VPWR sky130_fd_sc_hd__decap_3
XFILLER_59_86 VGND VGND VPWR VPWR sky130_fd_sc_hd__fill_2
XFILLER_78_224 VGND VGND VPWR VPWR sky130_fd_sc_hd__decap_3
XTAP_TAPCELL_ROW_111_1649 VGND VPWR sky130_fd_sc_hd__tapvpwrvgnd_1
XFILLER_115_81 VGND VGND VPWR VPWR sky130_fd_sc_hd__decap_3
XFILLER_19_357 VGND VGND VPWR VPWR sky130_fd_sc_hd__decap_3
XFILLER_47_644 VGND VGND VPWR VPWR sky130_fd_sc_hd__decap_3
XFILLER_19_379 VGND VGND VPWR VPWR sky130_fd_sc_hd__decap_3
XFILLER_46_165 VGND VGND VPWR VPWR sky130_fd_sc_hd__decap_3
XFILLER_47_688 VGND VGND VPWR VPWR sky130_fd_sc_hd__decap_3
XFILLER_62_614 VGND VGND VPWR VPWR sky130_fd_sc_hd__decap_3
XFILLER_61_113 VGND VGND VPWR VPWR sky130_fd_sc_hd__decap_3
XTAP_TAPCELL_ROW_45_823 VGND VPWR sky130_fd_sc_hd__tapvpwrvgnd_1
XFILLER_61_146 VGND VGND VPWR VPWR sky130_fd_sc_hd__decap_3
XFILLER_62_669 VGND VGND VPWR VPWR sky130_fd_sc_hd__decap_3
XFILLER_91_40 VGND VGND VPWR VPWR sky130_fd_sc_hd__decap_3
XFILLER_15_596 VGND VGND VPWR VPWR sky130_fd_sc_hd__decap_3
XFILLER_42_382 VGND VGND VPWR VPWR sky130_fd_sc_hd__decap_3
XFILLER_91_95 VGND VGND VPWR VPWR sky130_fd_sc_hd__decap_3
X_3520_ _5118_/D _3354_/X _3519_/Y _3350_/B VGND VGND VPWR VPWR _3525_/B sky130_fd_sc_hd__o2bb2a_2
XFILLER_116_616 VGND VGND VPWR VPWR sky130_fd_sc_hd__decap_3
Xhold707 _6880_/Q VGND VGND VPWR VPWR _6880_/D sky130_fd_sc_hd__dlygate4sd3_1
Xhold718 _6751_/Q VGND VGND VPWR VPWR _6751_/D sky130_fd_sc_hd__dlygate4sd3_1
Xwire671 _3591_/Y VGND VGND VPWR VPWR wire671/X sky130_fd_sc_hd__buf_1
XTAP_TAPCELL_ROW_77_1224 VGND VPWR sky130_fd_sc_hd__tapvpwrvgnd_1
Xhold729 _6724_/Q VGND VGND VPWR VPWR _6724_/D sky130_fd_sc_hd__dlygate4sd3_1
XFILLER_41_3 VGND VGND VPWR VPWR sky130_fd_sc_hd__decap_3
XFILLER_97_544 VGND VGND VPWR VPWR sky130_fd_sc_hd__decap_3
X_5121_ _5092_/C _5117_/X _5118_/X _6984_/D _5642_/A VGND VGND VPWR VPWR _5121_/X
+ sky130_fd_sc_hd__a32o_2
XFILLER_85_706 VGND VGND VPWR VPWR sky130_fd_sc_hd__decap_3
XFILLER_111_365 VGND VGND VPWR VPWR sky130_fd_sc_hd__decap_3
XFILLER_38_622 VGND VGND VPWR VPWR sky130_fd_sc_hd__decap_3
XFILLER_84_227 VGND VGND VPWR VPWR sky130_fd_sc_hd__decap_3
X_5052_ _3548_/X _5049_/X _5051_/X _3618_/X VGND VGND VPWR VPWR _5052_/X sky130_fd_sc_hd__a2bb2o_2
XFILLER_77_290 VGND VGND VPWR VPWR sky130_fd_sc_hd__decap_3
XFILLER_37_165 VGND VGND VPWR VPWR sky130_fd_sc_hd__decap_3
XFILLER_38_666 VGND VGND VPWR VPWR sky130_fd_sc_hd__decap_3
XFILLER_38_699 VGND VGND VPWR VPWR sky130_fd_sc_hd__fill_1
XFILLER_65_452 VGND VGND VPWR VPWR sky130_fd_sc_hd__decap_3
XTAP_TAPCELL_ROW_88_1364 VGND VPWR sky130_fd_sc_hd__tapvpwrvgnd_1
XTAP_TAPCELL_ROW_88_1353 VGND VPWR sky130_fd_sc_hd__tapvpwrvgnd_1
XFILLER_37_176 VGND VGND VPWR VPWR sky130_fd_sc_hd__decap_3
XFILLER_53_647 VGND VGND VPWR VPWR sky130_fd_sc_hd__decap_3
XFILLER_65_485 VGND VGND VPWR VPWR sky130_fd_sc_hd__decap_3
XFILLER_111_39 VGND VGND VPWR VPWR sky130_fd_sc_hd__decap_3
XFILLER_52_135 VGND VGND VPWR VPWR sky130_fd_sc_hd__decap_3
XFILLER_52_168 VGND VGND VPWR VPWR sky130_fd_sc_hd__decap_3
XFILLER_80_466 VGND VGND VPWR VPWR sky130_fd_sc_hd__decap_3
XFILLER_61_691 VGND VGND VPWR VPWR sky130_fd_sc_hd__decap_3
X_4905_ _4970_/A1 _4888_/A _4903_/A _5101_/A VGND VGND VPWR VPWR _4905_/X sky130_fd_sc_hd__o2bb2a_2
XFILLER_33_393 VGND VGND VPWR VPWR sky130_fd_sc_hd__decap_3
X_4836_ _7001_/D _4835_/X _4836_/S VGND VGND VPWR VPWR _4836_/X sky130_fd_sc_hd__mux2_2
XFILLER_21_588 VGND VGND VPWR VPWR sky130_fd_sc_hd__decap_3
XFILLER_119_432 VGND VGND VPWR VPWR sky130_fd_sc_hd__decap_3
X_6506_ _6631_/A VGND VGND VPWR VPWR _6506_/Y sky130_fd_sc_hd__inv_2
X_4767_ _5057_/A _4452_/A _4453_/A _4852_/A _4766_/Y VGND VGND VPWR VPWR _4767_/X
+ sky130_fd_sc_hd__o221a_2
XFILLER_106_104 VGND VGND VPWR VPWR sky130_fd_sc_hd__decap_3
XFILLER_107_638 VGND VGND VPWR VPWR sky130_fd_sc_hd__decap_3
XFILLER_112_9 VGND VGND VPWR VPWR sky130_fd_sc_hd__decap_3
XFILLER_119_498 VGND VGND VPWR VPWR sky130_fd_sc_hd__decap_3
X_4698_ _6985_/Q _5120_/A VGND VGND VPWR VPWR _5098_/A sky130_fd_sc_hd__and2_2
XTAP_TAPCELL_ROW_99_1493 VGND VPWR sky130_fd_sc_hd__tapvpwrvgnd_1
XFILLER_106_137 VGND VGND VPWR VPWR sky130_fd_sc_hd__decap_3
X_6437_ _6533_/A VGND VGND VPWR VPWR _6437_/Y sky130_fd_sc_hd__inv_2
XFILLER_115_671 VGND VGND VPWR VPWR sky130_fd_sc_hd__fill_1
X_6368_ _6635_/A VGND VGND VPWR VPWR _6368_/Y sky130_fd_sc_hd__inv_2
XFILLER_102_321 VGND VGND VPWR VPWR sky130_fd_sc_hd__decap_3
XFILLER_115_682 VGND VGND VPWR VPWR sky130_fd_sc_hd__decap_3
XFILLER_88_544 VGND VGND VPWR VPWR sky130_fd_sc_hd__decap_3
X_5319_ _7171_/Q _4913_/X _5323_/S VGND VGND VPWR VPWR _7171_/D sky130_fd_sc_hd__mux2_2
XFILLER_102_354 VGND VGND VPWR VPWR sky130_fd_sc_hd__decap_3
XFILLER_88_566 VGND VGND VPWR VPWR sky130_fd_sc_hd__decap_3
X_6299_ _6550_/A VGND VGND VPWR VPWR _6299_/Y sky130_fd_sc_hd__inv_2
XFILLER_102_365 VGND VGND VPWR VPWR sky130_fd_sc_hd__fill_2
XFILLER_29_600 VGND VGND VPWR VPWR sky130_fd_sc_hd__decap_3
XFILLER_75_205 VGND VGND VPWR VPWR sky130_fd_sc_hd__decap_3
XFILLER_28_121 VGND VGND VPWR VPWR sky130_fd_sc_hd__fill_1
XFILLER_29_644 VGND VGND VPWR VPWR sky130_fd_sc_hd__decap_3
XFILLER_56_430 VGND VGND VPWR VPWR sky130_fd_sc_hd__decap_3
XFILLER_75_249 VGND VGND VPWR VPWR sky130_fd_sc_hd__decap_3
XFILLER_91_709 VGND VGND VPWR VPWR sky130_fd_sc_hd__decap_3
XFILLER_16_305 VGND VGND VPWR VPWR sky130_fd_sc_hd__decap_3
XFILLER_28_165 VGND VGND VPWR VPWR sky130_fd_sc_hd__decap_3
XFILLER_29_688 VGND VGND VPWR VPWR sky130_fd_sc_hd__decap_3
XFILLER_45_11 VGND VGND VPWR VPWR sky130_fd_sc_hd__fill_1
XFILLER_83_260 VGND VGND VPWR VPWR sky130_fd_sc_hd__decap_3
XFILLER_44_625 VGND VGND VPWR VPWR sky130_fd_sc_hd__decap_3
XFILLER_56_485 VGND VGND VPWR VPWR sky130_fd_sc_hd__decap_3
XTAP_TAPCELL_ROW_3_297 VGND VPWR sky130_fd_sc_hd__tapvpwrvgnd_1
XFILLER_44_669 VGND VGND VPWR VPWR sky130_fd_sc_hd__decap_3
XFILLER_45_66 VGND VGND VPWR VPWR sky130_fd_sc_hd__decap_3
XFILLER_45_99 VGND VGND VPWR VPWR sky130_fd_sc_hd__decap_3
XFILLER_51_190 VGND VGND VPWR VPWR sky130_fd_sc_hd__decap_3
XTAP_TAPCELL_ROW_61_1025 VGND VPWR sky130_fd_sc_hd__tapvpwrvgnd_1
XFILLER_12_566 VGND VGND VPWR VPWR sky130_fd_sc_hd__decap_3
XFILLER_8_548 VGND VGND VPWR VPWR sky130_fd_sc_hd__decap_3
XTAP_TAPCELL_ROW_50_881 VGND VPWR sky130_fd_sc_hd__tapvpwrvgnd_1
XFILLER_4_710 VGND VGND VPWR VPWR sky130_fd_sc_hd__decap_3
XFILLER_106_660 VGND VGND VPWR VPWR sky130_fd_sc_hd__decap_3
XFILLER_3_231 VGND VGND VPWR VPWR sky130_fd_sc_hd__fill_1
XFILLER_106_693 VGND VGND VPWR VPWR sky130_fd_sc_hd__decap_3
XFILLER_3_264 VGND VGND VPWR VPWR sky130_fd_sc_hd__decap_3
XFILLER_79_511 VGND VGND VPWR VPWR sky130_fd_sc_hd__decap_3
XFILLER_105_181 VGND VGND VPWR VPWR sky130_fd_sc_hd__decap_3
XFILLER_67_706 VGND VGND VPWR VPWR sky130_fd_sc_hd__decap_3
XFILLER_79_544 VGND VGND VPWR VPWR sky130_fd_sc_hd__fill_1
XTAP_TAPCELL_ROW_72_1154 VGND VPWR sky130_fd_sc_hd__tapvpwrvgnd_1
XFILLER_66_227 VGND VGND VPWR VPWR sky130_fd_sc_hd__decap_3
XFILLER_86_73 VGND VGND VPWR VPWR sky130_fd_sc_hd__decap_3
XFILLER_47_430 VGND VGND VPWR VPWR sky130_fd_sc_hd__fill_1
XFILLER_35_603 VGND VGND VPWR VPWR sky130_fd_sc_hd__decap_3
XFILLER_35_647 VGND VGND VPWR VPWR sky130_fd_sc_hd__decap_3
XFILLER_62_433 VGND VGND VPWR VPWR sky130_fd_sc_hd__decap_3
XFILLER_74_282 VGND VGND VPWR VPWR sky130_fd_sc_hd__fill_1
XTAP_TAPCELL_ROW_58_981 VGND VPWR sky130_fd_sc_hd__tapvpwrvgnd_1
XFILLER_62_466 VGND VGND VPWR VPWR sky130_fd_sc_hd__fill_2
XFILLER_15_371 VGND VGND VPWR VPWR sky130_fd_sc_hd__fill_1
XFILLER_50_617 VGND VGND VPWR VPWR sky130_fd_sc_hd__decap_3
XFILLER_62_477 VGND VGND VPWR VPWR sky130_fd_sc_hd__decap_3
XFILLER_15_393 VGND VGND VPWR VPWR sky130_fd_sc_hd__decap_3
XFILLER_30_330 VGND VGND VPWR VPWR sky130_fd_sc_hd__decap_3
XFILLER_42_190 VGND VGND VPWR VPWR sky130_fd_sc_hd__decap_3
XFILLER_43_691 VGND VGND VPWR VPWR sky130_fd_sc_hd__decap_3
X_5670_ _5670_/A _5670_/B VGND VGND VPWR VPWR _5671_/B sky130_fd_sc_hd__nand2_2
XTAP_TAPCELL_ROW_83_1294 VGND VPWR sky130_fd_sc_hd__tapvpwrvgnd_1
XFILLER_30_363 VGND VGND VPWR VPWR sky130_fd_sc_hd__fill_1
XFILLER_89_3 VGND VGND VPWR VPWR sky130_fd_sc_hd__fill_2
X_4621_ _4315_/B _4343_/X _4315_/A VGND VGND VPWR VPWR _4621_/X sky130_fd_sc_hd__a21bo_2
XTAP_TAPCELL_ROW_20_509 VGND VPWR sky130_fd_sc_hd__tapvpwrvgnd_1
XFILLER_30_385 VGND VGND VPWR VPWR sky130_fd_sc_hd__decap_3
X_7340_ _7373_/CLK _7340_/D _6620_/Y VGND VGND VPWR VPWR _7340_/Q sky130_fd_sc_hd__dfrtp_2
X_4552_ _4552_/A _4563_/B VGND VGND VPWR VPWR _7304_/D sky130_fd_sc_hd__and2_2
XFILLER_116_435 VGND VGND VPWR VPWR sky130_fd_sc_hd__decap_3
XFILLER_7_570 VGND VGND VPWR VPWR sky130_fd_sc_hd__decap_3
X_7271_ _7406_/CLK _7271_/D _6551_/Y VGND VGND VPWR VPWR _7271_/Q sky130_fd_sc_hd__dfrtp_2
X_3503_ _3545_/A _3545_/B VGND VGND VPWR VPWR _3630_/A sky130_fd_sc_hd__xor2_4
XFILLER_104_619 VGND VGND VPWR VPWR sky130_fd_sc_hd__decap_3
XFILLER_89_319 VGND VGND VPWR VPWR sky130_fd_sc_hd__decap_3
X_3434_ _7218_/Q _4349_/B1 _4348_/B1 _7122_/Q VGND VGND VPWR VPWR _3434_/X sky130_fd_sc_hd__a22o_2
XFILLER_106_17 VGND VGND VPWR VPWR sky130_fd_sc_hd__decap_3
XFILLER_112_663 VGND VGND VPWR VPWR sky130_fd_sc_hd__decap_3
X_3365_ _3365_/A VGND VGND VPWR VPWR _5118_/A sky130_fd_sc_hd__inv_2
XFILLER_111_162 VGND VGND VPWR VPWR sky130_fd_sc_hd__decap_3
XFILLER_112_696 VGND VGND VPWR VPWR sky130_fd_sc_hd__decap_3
XFILLER_85_514 VGND VGND VPWR VPWR sky130_fd_sc_hd__fill_2
XFILLER_97_363 VGND VGND VPWR VPWR sky130_fd_sc_hd__decap_3
Xhold1204 _7131_/Q VGND VGND VPWR VPWR _5404_/A0 sky130_fd_sc_hd__dlygate4sd3_1
Xhold1215 _7167_/Q VGND VGND VPWR VPWR _5327_/A0 sky130_fd_sc_hd__dlygate4sd3_1
X_5104_ _5104_/A _5660_/C VGND VGND VPWR VPWR _5104_/Y sky130_fd_sc_hd__nand2_2
XFILLER_73_709 VGND VGND VPWR VPWR sky130_fd_sc_hd__decap_3
XFILLER_85_536 VGND VGND VPWR VPWR sky130_fd_sc_hd__decap_3
Xhold1226 _7129_/Q VGND VGND VPWR VPWR _5409_/A0 sky130_fd_sc_hd__dlygate4sd3_1
Xhold1237 _7301_/Q VGND VGND VPWR VPWR _4559_/A sky130_fd_sc_hd__dlygate4sd3_1
Xhold1248 _7318_/Q VGND VGND VPWR VPWR _4522_/A0 sky130_fd_sc_hd__dlygate4sd3_1
XFILLER_38_474 VGND VGND VPWR VPWR sky130_fd_sc_hd__fill_2
XFILLER_72_219 VGND VGND VPWR VPWR sky130_fd_sc_hd__decap_3
Xhold1259 _7249_/Q VGND VGND VPWR VPWR _5142_/A0 sky130_fd_sc_hd__dlygate4sd3_1
XTAP_TAPCELL_ROW_28_609 VGND VPWR sky130_fd_sc_hd__tapvpwrvgnd_1
XFILLER_25_102 VGND VGND VPWR VPWR sky130_fd_sc_hd__decap_3
XFILLER_25_113 VGND VGND VPWR VPWR sky130_fd_sc_hd__decap_3
XFILLER_26_625 VGND VGND VPWR VPWR sky130_fd_sc_hd__decap_3
XFILLER_53_411 VGND VGND VPWR VPWR sky130_fd_sc_hd__decap_3
XFILLER_93_591 VGND VGND VPWR VPWR sky130_fd_sc_hd__fill_1
XTAP_TAPCELL_ROW_0_245 VGND VPWR sky130_fd_sc_hd__tapvpwrvgnd_1
XFILLER_26_669 VGND VGND VPWR VPWR sky130_fd_sc_hd__decap_3
XFILLER_41_606 VGND VGND VPWR VPWR sky130_fd_sc_hd__decap_3
X_6986_ _7390_/CLK _6986_/D _6266_/Y VGND VGND VPWR VPWR _6986_/Q sky130_fd_sc_hd__dfrtp_2
XTAP_TAPCELL_ROW_0_256 VGND VPWR sky130_fd_sc_hd__tapvpwrvgnd_1
XFILLER_13_319 VGND VGND VPWR VPWR sky130_fd_sc_hd__decap_3
XFILLER_25_179 VGND VGND VPWR VPWR sky130_fd_sc_hd__decap_3
XFILLER_41_617 VGND VGND VPWR VPWR sky130_fd_sc_hd__decap_3
XFILLER_53_488 VGND VGND VPWR VPWR sky130_fd_sc_hd__fill_2
XFILLER_33_190 VGND VGND VPWR VPWR sky130_fd_sc_hd__fill_1
XFILLER_40_149 VGND VGND VPWR VPWR sky130_fd_sc_hd__decap_3
XFILLER_21_374 VGND VGND VPWR VPWR sky130_fd_sc_hd__decap_3
XFILLER_21_396 VGND VGND VPWR VPWR sky130_fd_sc_hd__fill_1
X_4819_ _7002_/Q _4834_/A _4818_/Y _4777_/A VGND VGND VPWR VPWR _4819_/X sky130_fd_sc_hd__o211a_2
XFILLER_31_46 VGND VGND VPWR VPWR sky130_fd_sc_hd__fill_2
XFILLER_31_57 VGND VGND VPWR VPWR sky130_fd_sc_hd__decap_3
XFILLER_107_435 VGND VGND VPWR VPWR sky130_fd_sc_hd__fill_1
XFILLER_119_284 VGND VGND VPWR VPWR sky130_fd_sc_hd__fill_2
XFILLER_107_479 VGND VGND VPWR VPWR sky130_fd_sc_hd__decap_3
XFILLER_0_234 VGND VGND VPWR VPWR sky130_fd_sc_hd__decap_3
XFILLER_103_641 VGND VGND VPWR VPWR sky130_fd_sc_hd__decap_3
XFILLER_49_706 VGND VGND VPWR VPWR sky130_fd_sc_hd__decap_3
XFILLER_88_341 VGND VGND VPWR VPWR sky130_fd_sc_hd__decap_3
XFILLER_88_352 VGND VGND VPWR VPWR sky130_fd_sc_hd__decap_3
XTAP_TAPCELL_ROW_8_356 VGND VPWR sky130_fd_sc_hd__tapvpwrvgnd_1
XFILLER_0_267 VGND VGND VPWR VPWR sky130_fd_sc_hd__decap_3
XFILLER_102_162 VGND VGND VPWR VPWR sky130_fd_sc_hd__decap_3
XFILLER_103_685 VGND VGND VPWR VPWR sky130_fd_sc_hd__decap_3
XFILLER_48_216 VGND VGND VPWR VPWR sky130_fd_sc_hd__decap_3
XFILLER_88_374 VGND VGND VPWR VPWR sky130_fd_sc_hd__decap_3
XFILLER_102_195 VGND VGND VPWR VPWR sky130_fd_sc_hd__fill_1
XFILLER_48_249 VGND VGND VPWR VPWR sky130_fd_sc_hd__decap_3
XFILLER_56_32 VGND VGND VPWR VPWR sky130_fd_sc_hd__fill_1
XFILLER_63_219 VGND VGND VPWR VPWR sky130_fd_sc_hd__decap_3
XFILLER_91_517 VGND VGND VPWR VPWR sky130_fd_sc_hd__decap_3
XFILLER_17_614 VGND VGND VPWR VPWR sky130_fd_sc_hd__fill_2
XFILLER_17_647 VGND VGND VPWR VPWR sky130_fd_sc_hd__decap_3
XFILLER_29_485 VGND VGND VPWR VPWR sky130_fd_sc_hd__fill_1
XFILLER_16_124 VGND VGND VPWR VPWR sky130_fd_sc_hd__fill_1
XFILLER_56_293 VGND VGND VPWR VPWR sky130_fd_sc_hd__decap_3
XTAP_TAPCELL_ROW_55_951 VGND VPWR sky130_fd_sc_hd__tapvpwrvgnd_1
XTAP_TAPCELL_ROW_55_940 VGND VPWR sky130_fd_sc_hd__tapvpwrvgnd_1
XPHY_EDGE_ROW_19_Right_19 VGND VGND VPWR VPWR sky130_fd_sc_hd__decap_3
XFILLER_112_71 VGND VGND VPWR VPWR sky130_fd_sc_hd__decap_3
XFILLER_32_628 VGND VGND VPWR VPWR sky130_fd_sc_hd__decap_3
XFILLER_44_477 VGND VGND VPWR VPWR sky130_fd_sc_hd__fill_1
XFILLER_25_691 VGND VGND VPWR VPWR sky130_fd_sc_hd__decap_3
XFILLER_31_149 VGND VGND VPWR VPWR sky130_fd_sc_hd__decap_3
XFILLER_12_363 VGND VGND VPWR VPWR sky130_fd_sc_hd__fill_1
XFILLER_40_672 VGND VGND VPWR VPWR sky130_fd_sc_hd__decap_3
XFILLER_8_312 VGND VGND VPWR VPWR sky130_fd_sc_hd__decap_3
XFILLER_12_396 VGND VGND VPWR VPWR sky130_fd_sc_hd__decap_3
XFILLER_75_9 VGND VGND VPWR VPWR sky130_fd_sc_hd__fill_2
Xclkbuf_3_1__f_clk clkbuf_0_clk/X VGND VGND VPWR VPWR clkbuf_leaf_6_clk/A sky130_fd_sc_hd__clkbuf_16
Xoutput609 _3429_/A VGND VGND VPWR VPWR instruction_out[15] sky130_fd_sc_hd__clkdlybuf4s25_1
XFILLER_4_551 VGND VGND VPWR VPWR sky130_fd_sc_hd__decap_3
XPHY_EDGE_ROW_28_Right_28 VGND VGND VPWR VPWR sky130_fd_sc_hd__decap_3
XFILLER_99_617 VGND VGND VPWR VPWR sky130_fd_sc_hd__decap_3
XFILLER_4_584 VGND VGND VPWR VPWR sky130_fd_sc_hd__decap_3
XFILLER_98_105 VGND VGND VPWR VPWR sky130_fd_sc_hd__decap_3
XFILLER_98_138 VGND VGND VPWR VPWR sky130_fd_sc_hd__fill_2
XFILLER_113_449 VGND VGND VPWR VPWR sky130_fd_sc_hd__decap_3
XFILLER_97_83 VGND VGND VPWR VPWR sky130_fd_sc_hd__decap_3
XFILLER_97_94 VGND VGND VPWR VPWR sky130_fd_sc_hd__decap_3
XFILLER_39_249 VGND VGND VPWR VPWR sky130_fd_sc_hd__decap_3
XFILLER_55_709 VGND VGND VPWR VPWR sky130_fd_sc_hd__decap_3
XFILLER_67_569 VGND VGND VPWR VPWR sky130_fd_sc_hd__decap_3
XFILLER_94_355 VGND VGND VPWR VPWR sky130_fd_sc_hd__decap_3
XFILLER_82_528 VGND VGND VPWR VPWR sky130_fd_sc_hd__decap_3
XTAP_TAPCELL_ROW_85_1323 VGND VPWR sky130_fd_sc_hd__tapvpwrvgnd_1
XPHY_EDGE_ROW_37_Right_37 VGND VGND VPWR VPWR sky130_fd_sc_hd__decap_3
XFILLER_23_606 VGND VGND VPWR VPWR sky130_fd_sc_hd__decap_3
X_6840_ _6983_/CLK _6840_/D VGND VGND VPWR VPWR _6840_/Q sky130_fd_sc_hd__dfxtp_2
XFILLER_23_617 VGND VGND VPWR VPWR sky130_fd_sc_hd__decap_3
X_6771_ clkload6/A _6771_/D VGND VGND VPWR VPWR _6771_/Q sky130_fd_sc_hd__dfxtp_2
X_3983_ _7349_/Q _4524_/A0 _3994_/S VGND VGND VPWR VPWR _7349_/D sky130_fd_sc_hd__mux2_2
XFILLER_31_650 VGND VGND VPWR VPWR sky130_fd_sc_hd__decap_3
XTAP_TAPCELL_ROW_33_667 VGND VPWR sky130_fd_sc_hd__tapvpwrvgnd_1
XFILLER_30_171 VGND VGND VPWR VPWR sky130_fd_sc_hd__decap_3
XFILLER_31_694 VGND VGND VPWR VPWR sky130_fd_sc_hd__decap_3
X_5653_ _5664_/B VGND VGND VPWR VPWR _5653_/Y sky130_fd_sc_hd__inv_2
XFILLER_117_700 VGND VGND VPWR VPWR sky130_fd_sc_hd__decap_3
XFILLER_30_193 VGND VGND VPWR VPWR sky130_fd_sc_hd__decap_3
X_4604_ _5602_/B VGND VGND VPWR VPWR _4671_/B sky130_fd_sc_hd__inv_2
XPHY_EDGE_ROW_46_Right_46 VGND VGND VPWR VPWR sky130_fd_sc_hd__decap_3
X_7323_ _7354_/CLK _7323_/D _6603_/Y VGND VGND VPWR VPWR _7323_/Q sky130_fd_sc_hd__dfrtp_2
XTAP_TAPCELL_ROW_96_1452 VGND VPWR sky130_fd_sc_hd__tapvpwrvgnd_1
XTAP_TAPCELL_ROW_96_1463 VGND VPWR sky130_fd_sc_hd__tapvpwrvgnd_1
XFILLER_104_427 VGND VGND VPWR VPWR sky130_fd_sc_hd__decap_3
XFILLER_117_38 VGND VGND VPWR VPWR sky130_fd_sc_hd__decap_3
XFILLER_89_116 VGND VGND VPWR VPWR sky130_fd_sc_hd__decap_3
X_7254_ _7350_/CLK _7254_/D _6534_/Y VGND VGND VPWR VPWR _7254_/Q sky130_fd_sc_hd__dfrtp_2
X_4466_ _5104_/A _5650_/A VGND VGND VPWR VPWR _4466_/Y sky130_fd_sc_hd__nand2_2
X_7185_ _7344_/CLK _7185_/D _6465_/Y VGND VGND VPWR VPWR _7185_/Q sky130_fd_sc_hd__dfrtp_2
X_4397_ _4397_/A _4648_/A VGND VGND VPWR VPWR _4447_/A sky130_fd_sc_hd__nor2_2
X_3417_ _3449_/B _3421_/C _3417_/C VGND VGND VPWR VPWR _3417_/X sky130_fd_sc_hd__and3_2
XFILLER_100_611 VGND VGND VPWR VPWR sky130_fd_sc_hd__decap_3
XFILLER_112_471 VGND VGND VPWR VPWR sky130_fd_sc_hd__decap_3
XFILLER_98_672 VGND VGND VPWR VPWR sky130_fd_sc_hd__decap_3
X_3348_ _3371_/A _3327_/B _3340_/A VGND VGND VPWR VPWR _5130_/A sky130_fd_sc_hd__a21oi_2
XTAP_TAPCELL_ROW_5_326 VGND VPWR sky130_fd_sc_hd__tapvpwrvgnd_1
XTAP_TAPCELL_ROW_5_315 VGND VPWR sky130_fd_sc_hd__tapvpwrvgnd_1
XFILLER_112_493 VGND VGND VPWR VPWR sky130_fd_sc_hd__decap_3
XFILLER_85_311 VGND VGND VPWR VPWR sky130_fd_sc_hd__decap_3
Xhold1001 _7101_/Q VGND VGND VPWR VPWR _7101_/D sky130_fd_sc_hd__dlygate4sd3_1
Xhold1012 _6688_/Q VGND VGND VPWR VPWR _5676_/A1 sky130_fd_sc_hd__dlygate4sd3_1
Xhold1023 _7031_/Q VGND VGND VPWR VPWR _5593_/A sky130_fd_sc_hd__dlygate4sd3_1
XFILLER_100_666 VGND VGND VPWR VPWR sky130_fd_sc_hd__decap_3
Xhold1034 _7394_/Q VGND VGND VPWR VPWR _3766_/A1 sky130_fd_sc_hd__dlygate4sd3_1
Xhold1045 _7028_/Q VGND VGND VPWR VPWR _5598_/A1 sky130_fd_sc_hd__dlygate4sd3_1
Xhold1056 _7011_/Q VGND VGND VPWR VPWR _5634_/A sky130_fd_sc_hd__dlygate4sd3_1
Xhold1067 _7052_/Q VGND VGND VPWR VPWR _5564_/A1 sky130_fd_sc_hd__dlygate4sd3_1
XPHY_EDGE_ROW_55_Right_55 VGND VGND VPWR VPWR sky130_fd_sc_hd__decap_3
XFILLER_100_699 VGND VGND VPWR VPWR sky130_fd_sc_hd__fill_1
XFILLER_85_388 VGND VGND VPWR VPWR sky130_fd_sc_hd__decap_3
XFILLER_85_399 VGND VGND VPWR VPWR sky130_fd_sc_hd__decap_3
Xhold1078 _7014_/Q VGND VGND VPWR VPWR _5628_/A sky130_fd_sc_hd__dlygate4sd3_1
Xhold1089 _7185_/Q VGND VGND VPWR VPWR _5288_/A0 sky130_fd_sc_hd__dlygate4sd3_1
X_5018_ _5018_/A _5018_/B VGND VGND VPWR VPWR _5018_/Y sky130_fd_sc_hd__nor2_2
XFILLER_26_455 VGND VGND VPWR VPWR sky130_fd_sc_hd__decap_3
XFILLER_14_628 VGND VGND VPWR VPWR sky130_fd_sc_hd__decap_3
XFILLER_26_477 VGND VGND VPWR VPWR sky130_fd_sc_hd__decap_3
XFILLER_53_252 VGND VGND VPWR VPWR sky130_fd_sc_hd__decap_3
XFILLER_81_561 VGND VGND VPWR VPWR sky130_fd_sc_hd__fill_1
XFILLER_81_583 VGND VGND VPWR VPWR sky130_fd_sc_hd__decap_3
XTAP_TAPCELL_ROW_52_910 VGND VPWR sky130_fd_sc_hd__tapvpwrvgnd_1
XFILLER_41_447 VGND VGND VPWR VPWR sky130_fd_sc_hd__fill_1
XFILLER_41_458 VGND VGND VPWR VPWR sky130_fd_sc_hd__decap_3
X_6969_ clkload3/A _6969_/D VGND VGND VPWR VPWR _6969_/Q sky130_fd_sc_hd__dfxtp_2
XTAP_TAPCELL_ROW_105_1570 VGND VPWR sky130_fd_sc_hd__tapvpwrvgnd_1
XFILLER_22_672 VGND VGND VPWR VPWR sky130_fd_sc_hd__decap_3
XPHY_EDGE_ROW_64_Right_64 VGND VGND VPWR VPWR sky130_fd_sc_hd__decap_3
XFILLER_107_210 VGND VGND VPWR VPWR sky130_fd_sc_hd__decap_3
XFILLER_5_337 VGND VGND VPWR VPWR sky130_fd_sc_hd__decap_3
XFILLER_107_243 VGND VGND VPWR VPWR sky130_fd_sc_hd__decap_3
XPHY_EDGE_ROW_39_Left_159 VGND VGND VPWR VPWR sky130_fd_sc_hd__decap_3
XPHY_EDGE_ROW_2_Left_122 VGND VGND VPWR VPWR sky130_fd_sc_hd__decap_3
XFILLER_107_265 VGND VGND VPWR VPWR sky130_fd_sc_hd__decap_3
XFILLER_107_287 VGND VGND VPWR VPWR sky130_fd_sc_hd__decap_3
XFILLER_1_532 VGND VGND VPWR VPWR sky130_fd_sc_hd__decap_3
XFILLER_89_650 VGND VGND VPWR VPWR sky130_fd_sc_hd__decap_3
Xhold890 _6824_/Q VGND VGND VPWR VPWR _6824_/D sky130_fd_sc_hd__dlygate4sd3_1
XFILLER_107_60 VGND VGND VPWR VPWR sky130_fd_sc_hd__decap_3
XFILLER_107_93 VGND VGND VPWR VPWR sky130_fd_sc_hd__decap_3
XFILLER_110_408 VGND VGND VPWR VPWR sky130_fd_sc_hd__decap_3
XFILLER_1_576 VGND VGND VPWR VPWR sky130_fd_sc_hd__decap_3
XFILLER_49_514 VGND VGND VPWR VPWR sky130_fd_sc_hd__decap_3
XFILLER_67_20 VGND VGND VPWR VPWR sky130_fd_sc_hd__fill_1
XFILLER_95_119 VGND VGND VPWR VPWR sky130_fd_sc_hd__decap_3
XFILLER_88_171 VGND VGND VPWR VPWR sky130_fd_sc_hd__decap_3
XFILLER_89_694 VGND VGND VPWR VPWR sky130_fd_sc_hd__decap_3
XPHY_EDGE_ROW_73_Right_73 VGND VGND VPWR VPWR sky130_fd_sc_hd__decap_3
XFILLER_37_709 VGND VGND VPWR VPWR sky130_fd_sc_hd__decap_3
XFILLER_64_506 VGND VGND VPWR VPWR sky130_fd_sc_hd__decap_3
XFILLER_91_303 VGND VGND VPWR VPWR sky130_fd_sc_hd__decap_3
XFILLER_64_528 VGND VGND VPWR VPWR sky130_fd_sc_hd__decap_3
XFILLER_29_293 VGND VGND VPWR VPWR sky130_fd_sc_hd__decap_3
XFILLER_83_41 VGND VGND VPWR VPWR sky130_fd_sc_hd__decap_3
XFILLER_91_369 VGND VGND VPWR VPWR sky130_fd_sc_hd__decap_3
XPHY_EDGE_ROW_48_Left_168 VGND VGND VPWR VPWR sky130_fd_sc_hd__decap_3
XFILLER_17_477 VGND VGND VPWR VPWR sky130_fd_sc_hd__decap_3
XFILLER_32_403 VGND VGND VPWR VPWR sky130_fd_sc_hd__decap_3
XFILLER_60_701 VGND VGND VPWR VPWR sky130_fd_sc_hd__decap_3
XFILLER_83_63 VGND VGND VPWR VPWR sky130_fd_sc_hd__decap_3
XFILLER_44_285 VGND VGND VPWR VPWR sky130_fd_sc_hd__fill_2
XTAP_TAPCELL_ROW_67_1097 VGND VPWR sky130_fd_sc_hd__tapvpwrvgnd_1
XFILLER_13_650 VGND VGND VPWR VPWR sky130_fd_sc_hd__decap_3
XFILLER_32_469 VGND VGND VPWR VPWR sky130_fd_sc_hd__decap_3
XTAP_TAPCELL_ROW_80_1253 VGND VPWR sky130_fd_sc_hd__tapvpwrvgnd_1
XPHY_EDGE_ROW_82_Right_82 VGND VGND VPWR VPWR sky130_fd_sc_hd__decap_3
XFILLER_12_160 VGND VGND VPWR VPWR sky130_fd_sc_hd__fill_2
XFILLER_13_694 VGND VGND VPWR VPWR sky130_fd_sc_hd__decap_3
XFILLER_40_480 VGND VGND VPWR VPWR sky130_fd_sc_hd__decap_3
XTAP_TAPCELL_ROW_80_1264 VGND VPWR sky130_fd_sc_hd__tapvpwrvgnd_1
XTAP_TAPCELL_ROW_30_637 VGND VPWR sky130_fd_sc_hd__tapvpwrvgnd_1
XFILLER_9_632 VGND VGND VPWR VPWR sky130_fd_sc_hd__decap_3
XFILLER_118_519 VGND VGND VPWR VPWR sky130_fd_sc_hd__decap_3
XFILLER_8_131 VGND VGND VPWR VPWR sky130_fd_sc_hd__decap_3
XFILLER_9_676 VGND VGND VPWR VPWR sky130_fd_sc_hd__decap_3
XFILLER_9_665 VGND VGND VPWR VPWR sky130_fd_sc_hd__decap_3
XPHY_EDGE_ROW_57_Left_177 VGND VGND VPWR VPWR sky130_fd_sc_hd__decap_3
XTAP_TAPCELL_ROW_10_383 VGND VPWR sky130_fd_sc_hd__tapvpwrvgnd_1
XFILLER_99_403 VGND VGND VPWR VPWR sky130_fd_sc_hd__decap_3
X_4320_ _7066_/Q _4305_/B _4460_/A VGND VGND VPWR VPWR _4362_/B sky130_fd_sc_hd__o21a_2
XFILLER_99_436 VGND VGND VPWR VPWR sky130_fd_sc_hd__decap_3
X_4251_ _7016_/Q _4601_/S _4333_/A2 _7133_/Q _4250_/X VGND VGND VPWR VPWR _4251_/X
+ sky130_fd_sc_hd__a221o_2
XFILLER_99_458 VGND VGND VPWR VPWR sky130_fd_sc_hd__decap_3
XPHY_EDGE_ROW_91_Right_91 VGND VGND VPWR VPWR sky130_fd_sc_hd__decap_3
XFILLER_95_620 VGND VGND VPWR VPWR sky130_fd_sc_hd__decap_3
X_4182_ _7136_/Q _4351_/B1 _4180_/X _4181_/X VGND VGND VPWR VPWR _4182_/X sky130_fd_sc_hd__a211o_2
XTAP_TAPCELL_ROW_91_1393 VGND VPWR sky130_fd_sc_hd__tapvpwrvgnd_1
XFILLER_55_517 VGND VGND VPWR VPWR sky130_fd_sc_hd__decap_3
XFILLER_67_366 VGND VGND VPWR VPWR sky130_fd_sc_hd__decap_3
XFILLER_95_653 VGND VGND VPWR VPWR sky130_fd_sc_hd__decap_3
XFILLER_27_219 VGND VGND VPWR VPWR sky130_fd_sc_hd__decap_3
XFILLER_67_399 VGND VGND VPWR VPWR sky130_fd_sc_hd__fill_2
XFILLER_95_697 VGND VGND VPWR VPWR sky130_fd_sc_hd__decap_3
XTAP_TAPCELL_ROW_38_737 VGND VPWR sky130_fd_sc_hd__tapvpwrvgnd_1
XPHY_EDGE_ROW_66_Left_186 VGND VGND VPWR VPWR sky130_fd_sc_hd__decap_3
XFILLER_70_509 VGND VGND VPWR VPWR sky130_fd_sc_hd__decap_3
XFILLER_50_200 VGND VGND VPWR VPWR sky130_fd_sc_hd__decap_3
XFILLER_51_712 VGND VGND VPWR VPWR sky130_fd_sc_hd__fill_2
XFILLER_63_561 VGND VGND VPWR VPWR sky130_fd_sc_hd__decap_3
XFILLER_23_447 VGND VGND VPWR VPWR sky130_fd_sc_hd__fill_1
XFILLER_50_233 VGND VGND VPWR VPWR sky130_fd_sc_hd__decap_3
XFILLER_90_380 VGND VGND VPWR VPWR sky130_fd_sc_hd__decap_3
Xplace550 _6612_/A VGND VGND VPWR VPWR _6610_/A sky130_fd_sc_hd__buf_2
Xplace561 _6625_/A VGND VGND VPWR VPWR _6463_/A sky130_fd_sc_hd__buf_2
X_6823_ _6906_/CLK _6823_/D VGND VGND VPWR VPWR _6823_/Q sky130_fd_sc_hd__dfxtp_2
XTAP_TAPCELL_ROW_18_483 VGND VPWR sky130_fd_sc_hd__tapvpwrvgnd_1
XFILLER_11_609 VGND VGND VPWR VPWR sky130_fd_sc_hd__decap_3
XFILLER_23_469 VGND VGND VPWR VPWR sky130_fd_sc_hd__decap_3
X_6754_ clkload8/A _6754_/D VGND VGND VPWR VPWR _6754_/Q sky130_fd_sc_hd__dfxtp_2
X_3966_ _7357_/Q _4509_/A1 _3966_/S VGND VGND VPWR VPWR _7357_/D sky130_fd_sc_hd__mux2_2
XFILLER_50_277 VGND VGND VPWR VPWR sky130_fd_sc_hd__fill_1
X_6685_ _6686_/A VGND VGND VPWR VPWR _6685_/Y sky130_fd_sc_hd__inv_2
X_5705_ _5705_/A1 _5721_/S _4270_/Y VGND VGND VPWR VPWR _6702_/D sky130_fd_sc_hd__a21bo_2
XFILLER_31_491 VGND VGND VPWR VPWR sky130_fd_sc_hd__decap_3
X_3897_ _3897_/A1 _5104_/A _3896_/Y VGND VGND VPWR VPWR _7382_/D sky130_fd_sc_hd__a21bo_2
XPHY_EDGE_ROW_75_Left_195 VGND VGND VPWR VPWR sky130_fd_sc_hd__decap_3
XFILLER_12_59 VGND VGND VPWR VPWR sky130_fd_sc_hd__decap_3
XFILLER_105_703 VGND VGND VPWR VPWR sky130_fd_sc_hd__decap_3
X_5567_ _5567_/A1 _4960_/A _4870_/Y VGND VGND VPWR VPWR _7050_/D sky130_fd_sc_hd__a21o_2
XFILLER_117_585 VGND VGND VPWR VPWR sky130_fd_sc_hd__decap_3
XFILLER_2_329 VGND VGND VPWR VPWR sky130_fd_sc_hd__decap_3
X_7306_ _7342_/CLK _7306_/D _6586_/Y VGND VGND VPWR VPWR _7306_/Q sky130_fd_sc_hd__dfrtp_2
XFILLER_104_224 VGND VGND VPWR VPWR sky130_fd_sc_hd__decap_3
X_7237_ _7370_/CLK _7237_/D _6517_/Y VGND VGND VPWR VPWR _7237_/Q sky130_fd_sc_hd__dfrtp_2
X_4449_ _4403_/A _4411_/B _4448_/X VGND VGND VPWR VPWR _4761_/C sky130_fd_sc_hd__a21oi_2
XFILLER_104_268 VGND VGND VPWR VPWR sky130_fd_sc_hd__decap_3
XFILLER_58_300 VGND VGND VPWR VPWR sky130_fd_sc_hd__fill_1
XFILLER_77_119 VGND VGND VPWR VPWR sky130_fd_sc_hd__decap_3
XFILLER_98_480 VGND VGND VPWR VPWR sky130_fd_sc_hd__decap_3
X_7168_ _7362_/CLK _7168_/D _6448_/Y VGND VGND VPWR VPWR _7168_/Q sky130_fd_sc_hd__dfrtp_2
XFILLER_100_452 VGND VGND VPWR VPWR sky130_fd_sc_hd__decap_3
XFILLER_19_709 VGND VGND VPWR VPWR sky130_fd_sc_hd__decap_3
XFILLER_85_152 VGND VGND VPWR VPWR sky130_fd_sc_hd__decap_3
XFILLER_86_675 VGND VGND VPWR VPWR sky130_fd_sc_hd__decap_3
X_7099_ _7322_/CLK _7099_/D _6379_/Y VGND VGND VPWR VPWR _7099_/Q sky130_fd_sc_hd__dfrtp_2
XFILLER_58_377 VGND VGND VPWR VPWR sky130_fd_sc_hd__decap_3
XFILLER_58_399 VGND VGND VPWR VPWR sky130_fd_sc_hd__fill_1
XFILLER_26_230 VGND VGND VPWR VPWR sky130_fd_sc_hd__decap_3
XFILLER_26_241 VGND VGND VPWR VPWR sky130_fd_sc_hd__decap_3
XFILLER_42_701 VGND VGND VPWR VPWR sky130_fd_sc_hd__decap_3
XFILLER_14_436 VGND VGND VPWR VPWR sky130_fd_sc_hd__decap_3
XFILLER_26_296 VGND VGND VPWR VPWR sky130_fd_sc_hd__decap_3
XFILLER_81_380 VGND VGND VPWR VPWR sky130_fd_sc_hd__decap_3
XFILLER_14_469 VGND VGND VPWR VPWR sky130_fd_sc_hd__decap_3
XFILLER_22_480 VGND VGND VPWR VPWR sky130_fd_sc_hd__decap_3
XFILLER_10_631 VGND VGND VPWR VPWR sky130_fd_sc_hd__decap_3
XFILLER_10_675 VGND VGND VPWR VPWR sky130_fd_sc_hd__decap_3
XFILLER_6_613 VGND VGND VPWR VPWR sky130_fd_sc_hd__decap_3
XFILLER_6_657 VGND VGND VPWR VPWR sky130_fd_sc_hd__decap_3
XFILLER_111_706 VGND VGND VPWR VPWR sky130_fd_sc_hd__decap_3
XFILLER_78_74 VGND VGND VPWR VPWR sky130_fd_sc_hd__decap_3
XFILLER_78_85 VGND VGND VPWR VPWR sky130_fd_sc_hd__decap_3
XFILLER_110_238 VGND VGND VPWR VPWR sky130_fd_sc_hd__decap_3
XFILLER_77_620 VGND VGND VPWR VPWR sky130_fd_sc_hd__decap_3
XFILLER_49_355 VGND VGND VPWR VPWR sky130_fd_sc_hd__fill_2
XFILLER_76_141 VGND VGND VPWR VPWR sky130_fd_sc_hd__decap_3
XFILLER_77_653 VGND VGND VPWR VPWR sky130_fd_sc_hd__decap_3
XFILLER_49_399 VGND VGND VPWR VPWR sky130_fd_sc_hd__fill_1
XFILLER_76_163 VGND VGND VPWR VPWR sky130_fd_sc_hd__fill_1
XFILLER_77_697 VGND VGND VPWR VPWR sky130_fd_sc_hd__decap_3
XFILLER_92_634 VGND VGND VPWR VPWR sky130_fd_sc_hd__decap_3
XTAP_TAPCELL_ROW_69_1126 VGND VPWR sky130_fd_sc_hd__tapvpwrvgnd_1
XTAP_TAPCELL_ROW_69_1115 VGND VPWR sky130_fd_sc_hd__tapvpwrvgnd_1
XFILLER_64_347 VGND VGND VPWR VPWR sky130_fd_sc_hd__decap_3
XFILLER_91_133 VGND VGND VPWR VPWR sky130_fd_sc_hd__decap_3
XFILLER_92_645 VGND VGND VPWR VPWR sky130_fd_sc_hd__decap_3
XFILLER_33_712 VGND VGND VPWR VPWR sky130_fd_sc_hd__fill_2
XFILLER_45_561 VGND VGND VPWR VPWR sky130_fd_sc_hd__decap_3
XFILLER_91_166 VGND VGND VPWR VPWR sky130_fd_sc_hd__fill_2
XFILLER_92_678 VGND VGND VPWR VPWR sky130_fd_sc_hd__decap_3
XFILLER_32_200 VGND VGND VPWR VPWR sky130_fd_sc_hd__fill_1
XFILLER_72_391 VGND VGND VPWR VPWR sky130_fd_sc_hd__decap_3
XFILLER_91_199 VGND VGND VPWR VPWR sky130_fd_sc_hd__decap_3
XFILLER_20_406 VGND VGND VPWR VPWR sky130_fd_sc_hd__decap_3
XFILLER_60_575 VGND VGND VPWR VPWR sky130_fd_sc_hd__decap_3
X_3820_ _6927_/Q _3926_/A2 _3925_/A2 _6701_/Q VGND VGND VPWR VPWR _3820_/X sky130_fd_sc_hd__a22o_2
XTAP_TAPCELL_ROW_15_442 VGND VPWR sky130_fd_sc_hd__tapvpwrvgnd_1
XFILLER_32_277 VGND VGND VPWR VPWR sky130_fd_sc_hd__decap_3
XFILLER_32_299 VGND VGND VPWR VPWR sky130_fd_sc_hd__decap_3
X_3751_ _6935_/Q _3926_/A2 _3767_/B1 _6887_/Q VGND VGND VPWR VPWR _3751_/X sky130_fd_sc_hd__a22o_2
XTAP_TAPCELL_ROW_43_795 VGND VPWR sky130_fd_sc_hd__tapvpwrvgnd_1
XFILLER_118_338 VGND VGND VPWR VPWR sky130_fd_sc_hd__decap_3
XFILLER_71_3 VGND VGND VPWR VPWR sky130_fd_sc_hd__decap_3
X_6470_ _6598_/A VGND VGND VPWR VPWR _6470_/Y sky130_fd_sc_hd__inv_2
X_3682_ _3682_/A _3682_/B VGND VGND VPWR VPWR _3682_/Y sky130_fd_sc_hd__nand2_2
X_5421_ _7123_/Q _5135_/X _5429_/S VGND VGND VPWR VPWR _7123_/D sky130_fd_sc_hd__mux2_2
X_5352_ _5352_/A0 _5135_/X _5360_/S VGND VGND VPWR VPWR _7155_/D sky130_fd_sc_hd__mux2_2
XTAP_TAPCELL_ROW_93_1422 VGND VPWR sky130_fd_sc_hd__tapvpwrvgnd_1
XFILLER_99_200 VGND VGND VPWR VPWR sky130_fd_sc_hd__fill_2
XFILLER_114_544 VGND VGND VPWR VPWR sky130_fd_sc_hd__decap_3
X_4303_ _7320_/Q _3996_/S _4348_/B1 _7128_/Q _4302_/X VGND VGND VPWR VPWR _4303_/X
+ sky130_fd_sc_hd__a221o_2
XFILLER_99_233 VGND VGND VPWR VPWR sky130_fd_sc_hd__decap_3
XFILLER_59_108 VGND VGND VPWR VPWR sky130_fd_sc_hd__decap_3
XFILLER_59_119 VGND VGND VPWR VPWR sky130_fd_sc_hd__decap_3
XFILLER_87_406 VGND VGND VPWR VPWR sky130_fd_sc_hd__decap_3
X_7022_ _7402_/CLK _7022_/D _6302_/Y VGND VGND VPWR VPWR _7022_/Q sky130_fd_sc_hd__dfrtp_2
X_5283_ _3600_/A _4788_/A _5238_/X _5283_/B2 VGND VGND VPWR VPWR _7188_/D sky130_fd_sc_hd__a22o_2
XFILLER_99_266 VGND VGND VPWR VPWR sky130_fd_sc_hd__decap_3
XFILLER_87_439 VGND VGND VPWR VPWR sky130_fd_sc_hd__decap_3
X_4234_ _7355_/Q _4346_/B1 _4233_/X _4347_/C1 VGND VGND VPWR VPWR _4234_/X sky130_fd_sc_hd__a211o_2
XFILLER_114_17 VGND VGND VPWR VPWR sky130_fd_sc_hd__decap_3
XFILLER_68_642 VGND VGND VPWR VPWR sky130_fd_sc_hd__fill_2
XFILLER_68_675 VGND VGND VPWR VPWR sky130_fd_sc_hd__decap_3
X_4165_ _7018_/Q _4422_/A2 _4434_/B1 _7137_/Q _4164_/X VGND VGND VPWR VPWR _4165_/X
+ sky130_fd_sc_hd__a221o_2
XFILLER_28_528 VGND VGND VPWR VPWR sky130_fd_sc_hd__fill_1
XFILLER_82_100 VGND VGND VPWR VPWR sky130_fd_sc_hd__decap_3
XFILLER_83_623 VGND VGND VPWR VPWR sky130_fd_sc_hd__decap_3
XFILLER_82_133 VGND VGND VPWR VPWR sky130_fd_sc_hd__decap_3
XFILLER_82_144 VGND VGND VPWR VPWR sky130_fd_sc_hd__decap_3
XFILLER_83_656 VGND VGND VPWR VPWR sky130_fd_sc_hd__decap_3
X_4096_ _4096_/A _4096_/B VGND VGND VPWR VPWR _4633_/A sky130_fd_sc_hd__nand2_2
XFILLER_24_701 VGND VGND VPWR VPWR sky130_fd_sc_hd__decap_3
XFILLER_82_177 VGND VGND VPWR VPWR sky130_fd_sc_hd__decap_3
XFILLER_70_339 VGND VGND VPWR VPWR sky130_fd_sc_hd__decap_3
XFILLER_23_233 VGND VGND VPWR VPWR sky130_fd_sc_hd__fill_1
XFILLER_51_553 VGND VGND VPWR VPWR sky130_fd_sc_hd__decap_3
XFILLER_51_564 VGND VGND VPWR VPWR sky130_fd_sc_hd__decap_3
Xplace391 _4349_/B1 VGND VGND VPWR VPWR _4421_/A2 sky130_fd_sc_hd__buf_2
Xplace380 _4460_/A VGND VGND VPWR VPWR _4205_/A sky130_fd_sc_hd__buf_2
X_6806_ _6942_/CLK _6806_/D VGND VGND VPWR VPWR _6806_/Q sky130_fd_sc_hd__dfxtp_2
X_4998_ _4998_/A0 _4997_/X _5028_/S VGND VGND VPWR VPWR _7262_/D sky130_fd_sc_hd__mux2_2
XPHY_EDGE_ROW_83_Left_203 VGND VGND VPWR VPWR sky130_fd_sc_hd__decap_3
X_6737_ _6923_/CLK _6737_/D VGND VGND VPWR VPWR _6737_/Q sky130_fd_sc_hd__dfxtp_2
X_3949_ _7365_/Q _4493_/A0 _3952_/S VGND VGND VPWR VPWR _7365_/D sky130_fd_sc_hd__mux2_2
X_6668_ _6672_/A VGND VGND VPWR VPWR _6668_/Y sky130_fd_sc_hd__inv_2
X_6599_ _6631_/A VGND VGND VPWR VPWR _6599_/Y sky130_fd_sc_hd__inv_2
X_5619_ _5619_/A _5633_/B VGND VGND VPWR VPWR _7018_/D sky130_fd_sc_hd__or2_2
XFILLER_117_393 VGND VGND VPWR VPWR sky130_fd_sc_hd__fill_2
XFILLER_3_638 VGND VGND VPWR VPWR sky130_fd_sc_hd__decap_3
XPHY_EDGE_ROW_92_Left_212 VGND VGND VPWR VPWR sky130_fd_sc_hd__decap_3
XFILLER_59_620 VGND VGND VPWR VPWR sky130_fd_sc_hd__decap_3
XFILLER_58_141 VGND VGND VPWR VPWR sky130_fd_sc_hd__decap_3
XFILLER_59_653 VGND VGND VPWR VPWR sky130_fd_sc_hd__decap_3
XFILLER_100_271 VGND VGND VPWR VPWR sky130_fd_sc_hd__decap_3
XFILLER_59_697 VGND VGND VPWR VPWR sky130_fd_sc_hd__decap_3
XFILLER_74_612 VGND VGND VPWR VPWR sky130_fd_sc_hd__decap_3
XFILLER_86_472 VGND VGND VPWR VPWR sky130_fd_sc_hd__decap_3
XFILLER_86_483 VGND VGND VPWR VPWR sky130_fd_sc_hd__fill_2
XFILLER_100_293 VGND VGND VPWR VPWR sky130_fd_sc_hd__decap_3
XFILLER_73_122 VGND VGND VPWR VPWR sky130_fd_sc_hd__fill_1
XFILLER_74_645 VGND VGND VPWR VPWR sky130_fd_sc_hd__decap_3
XFILLER_104_94 VGND VGND VPWR VPWR sky130_fd_sc_hd__decap_3
XFILLER_15_712 VGND VGND VPWR VPWR sky130_fd_sc_hd__fill_2
XFILLER_64_54 VGND VGND VPWR VPWR sky130_fd_sc_hd__decap_3
XFILLER_73_166 VGND VGND VPWR VPWR sky130_fd_sc_hd__fill_2
XFILLER_74_678 VGND VGND VPWR VPWR sky130_fd_sc_hd__decap_3
XFILLER_27_594 VGND VGND VPWR VPWR sky130_fd_sc_hd__decap_3
XFILLER_30_704 VGND VGND VPWR VPWR sky130_fd_sc_hd__decap_3
XTAP_TAPCELL_ROW_64_1056 VGND VPWR sky130_fd_sc_hd__tapvpwrvgnd_1
XFILLER_14_277 VGND VGND VPWR VPWR sky130_fd_sc_hd__decap_3
XFILLER_42_586 VGND VGND VPWR VPWR sky130_fd_sc_hd__fill_2
XFILLER_42_597 VGND VGND VPWR VPWR sky130_fd_sc_hd__decap_3
XFILLER_80_64 VGND VGND VPWR VPWR sky130_fd_sc_hd__decap_3
XTAP_TAPCELL_ROW_40_754 VGND VPWR sky130_fd_sc_hd__tapvpwrvgnd_1
XTAP_TAPCELL_ROW_12_412 VGND VPWR sky130_fd_sc_hd__tapvpwrvgnd_1
XFILLER_6_410 VGND VGND VPWR VPWR sky130_fd_sc_hd__decap_3
XFILLER_80_97 VGND VGND VPWR VPWR sky130_fd_sc_hd__decap_3
XFILLER_10_494 VGND VGND VPWR VPWR sky130_fd_sc_hd__decap_3
XFILLER_6_432 VGND VGND VPWR VPWR sky130_fd_sc_hd__decap_3
XTAP_TAPCELL_ROW_116_1709 VGND VPWR sky130_fd_sc_hd__tapvpwrvgnd_1
XPHY_EDGE_ROW_108_Right_108 VGND VGND VPWR VPWR sky130_fd_sc_hd__decap_3
XFILLER_89_73 VGND VGND VPWR VPWR sky130_fd_sc_hd__decap_3
XFILLER_2_660 VGND VGND VPWR VPWR sky130_fd_sc_hd__decap_3
XFILLER_96_203 VGND VGND VPWR VPWR sky130_fd_sc_hd__fill_2
XTAP_TAPCELL_ROW_75_1196 VGND VPWR sky130_fd_sc_hd__tapvpwrvgnd_1
XFILLER_111_514 VGND VGND VPWR VPWR sky130_fd_sc_hd__decap_3
XFILLER_2_693 VGND VGND VPWR VPWR sky130_fd_sc_hd__decap_3
XFILLER_69_428 VGND VGND VPWR VPWR sky130_fd_sc_hd__decap_3
XFILLER_111_558 VGND VGND VPWR VPWR sky130_fd_sc_hd__fill_2
XFILLER_96_269 VGND VGND VPWR VPWR sky130_fd_sc_hd__decap_3
XFILLER_65_612 VGND VGND VPWR VPWR sky130_fd_sc_hd__decap_3
XFILLER_65_623 VGND VGND VPWR VPWR sky130_fd_sc_hd__decap_3
XFILLER_77_461 VGND VGND VPWR VPWR sky130_fd_sc_hd__decap_3
XFILLER_37_325 VGND VGND VPWR VPWR sky130_fd_sc_hd__fill_2
XFILLER_37_358 VGND VGND VPWR VPWR sky130_fd_sc_hd__fill_1
XFILLER_65_656 VGND VGND VPWR VPWR sky130_fd_sc_hd__decap_3
XTAP_TAPCELL_ROW_48_854 VGND VPWR sky130_fd_sc_hd__tapvpwrvgnd_1
XFILLER_64_144 VGND VGND VPWR VPWR sky130_fd_sc_hd__decap_3
XFILLER_64_177 VGND VGND VPWR VPWR sky130_fd_sc_hd__decap_3
XFILLER_80_615 VGND VGND VPWR VPWR sky130_fd_sc_hd__decap_3
XFILLER_92_453 VGND VGND VPWR VPWR sky130_fd_sc_hd__fill_2
XFILLER_92_486 VGND VGND VPWR VPWR sky130_fd_sc_hd__decap_3
XFILLER_18_583 VGND VGND VPWR VPWR sky130_fd_sc_hd__decap_3
XFILLER_52_339 VGND VGND VPWR VPWR sky130_fd_sc_hd__decap_3
XFILLER_80_648 VGND VGND VPWR VPWR sky130_fd_sc_hd__decap_3
X_4921_ _4968_/A _4383_/C _4201_/X VGND VGND VPWR VPWR _4937_/B sky130_fd_sc_hd__a21bo_2
XFILLER_33_542 VGND VGND VPWR VPWR sky130_fd_sc_hd__fill_2
XFILLER_33_553 VGND VGND VPWR VPWR sky130_fd_sc_hd__fill_1
X_4852_ _4852_/A _5057_/A VGND VGND VPWR VPWR _5101_/A sky130_fd_sc_hd__and2_2
XFILLER_20_214 VGND VGND VPWR VPWR sky130_fd_sc_hd__fill_1
XFILLER_33_597 VGND VGND VPWR VPWR sky130_fd_sc_hd__decap_3
XFILLER_60_383 VGND VGND VPWR VPWR sky130_fd_sc_hd__fill_2
X_3803_ _6816_/Q _3879_/B1 _3883_/B1 _6821_/Q VGND VGND VPWR VPWR _3803_/X sky130_fd_sc_hd__a22o_2
XFILLER_119_603 VGND VGND VPWR VPWR sky130_fd_sc_hd__decap_3
XFILLER_60_394 VGND VGND VPWR VPWR sky130_fd_sc_hd__fill_1
X_4783_ _4646_/A _4646_/B _4827_/A VGND VGND VPWR VPWR _4829_/B sky130_fd_sc_hd__a21boi_2
X_6522_ _6647_/A VGND VGND VPWR VPWR _6522_/Y sky130_fd_sc_hd__inv_2
X_3734_ _3728_/Y _3730_/X _3732_/X _3733_/X VGND VGND VPWR VPWR _3734_/X sky130_fd_sc_hd__a22o_2
XFILLER_9_270 VGND VGND VPWR VPWR sky130_fd_sc_hd__decap_3
XFILLER_119_669 VGND VGND VPWR VPWR sky130_fd_sc_hd__decap_3
X_6453_ _6645_/A VGND VGND VPWR VPWR _6453_/Y sky130_fd_sc_hd__inv_2
X_3665_ _3665_/A _3665_/B VGND VGND VPWR VPWR _3665_/X sky130_fd_sc_hd__and2_4
XFILLER_109_39 VGND VGND VPWR VPWR sky130_fd_sc_hd__decap_3
X_5404_ _5404_/A0 _5040_/X _5427_/S VGND VGND VPWR VPWR _7131_/D sky130_fd_sc_hd__mux2_2
X_6384_ _6639_/A VGND VGND VPWR VPWR _6384_/Y sky130_fd_sc_hd__inv_2
X_3596_ _4295_/B _3607_/B VGND VGND VPWR VPWR _3598_/A sky130_fd_sc_hd__and2_2
XFILLER_88_704 VGND VGND VPWR VPWR sky130_fd_sc_hd__decap_3
XFILLER_102_525 VGND VGND VPWR VPWR sky130_fd_sc_hd__decap_3
XFILLER_102_536 VGND VGND VPWR VPWR sky130_fd_sc_hd__decap_3
XFILLER_114_385 VGND VGND VPWR VPWR sky130_fd_sc_hd__decap_3
XFILLER_87_214 VGND VGND VPWR VPWR sky130_fd_sc_hd__decap_3
XFILLER_87_225 VGND VGND VPWR VPWR sky130_fd_sc_hd__decap_3
X_5266_ _5266_/A0 _5011_/X _5274_/S VGND VGND VPWR VPWR _7197_/D sky130_fd_sc_hd__mux2_2
XFILLER_87_258 VGND VGND VPWR VPWR sky130_fd_sc_hd__decap_3
X_7005_ _7373_/CLK _7005_/D _6285_/Y VGND VGND VPWR VPWR _7005_/Q sky130_fd_sc_hd__dfrtp_2
X_4217_ _3469_/A _3469_/B _3449_/A _7015_/Q _3365_/A VGND VGND VPWR VPWR _4217_/X
+ sky130_fd_sc_hd__o2111a_2
XFILLER_28_325 VGND VGND VPWR VPWR sky130_fd_sc_hd__fill_2
XFILLER_28_347 VGND VGND VPWR VPWR sky130_fd_sc_hd__decap_3
XFILLER_55_133 VGND VGND VPWR VPWR sky130_fd_sc_hd__decap_3
XFILLER_56_634 VGND VGND VPWR VPWR sky130_fd_sc_hd__decap_3
XFILLER_56_645 VGND VGND VPWR VPWR sky130_fd_sc_hd__decap_3
X_4148_ _7074_/Q _4265_/B _4145_/X _4147_/X VGND VGND VPWR VPWR _4205_/B sky130_fd_sc_hd__o22a_2
XFILLER_56_678 VGND VGND VPWR VPWR sky130_fd_sc_hd__decap_3
XFILLER_71_604 VGND VGND VPWR VPWR sky130_fd_sc_hd__decap_3
XFILLER_71_626 VGND VGND VPWR VPWR sky130_fd_sc_hd__decap_3
X_4079_ _7403_/Q _4181_/B1 _4077_/X _4078_/X VGND VGND VPWR VPWR _4079_/X sky130_fd_sc_hd__a211o_2
XFILLER_70_103 VGND VGND VPWR VPWR sky130_fd_sc_hd__decap_3
XFILLER_71_659 VGND VGND VPWR VPWR sky130_fd_sc_hd__decap_3
XFILLER_83_497 VGND VGND VPWR VPWR sky130_fd_sc_hd__decap_3
XFILLER_12_704 VGND VGND VPWR VPWR sky130_fd_sc_hd__decap_3
XFILLER_24_531 VGND VGND VPWR VPWR sky130_fd_sc_hd__fill_1
XFILLER_24_542 VGND VGND VPWR VPWR sky130_fd_sc_hd__fill_1
XFILLER_34_24 VGND VGND VPWR VPWR sky130_fd_sc_hd__decap_3
XFILLER_70_136 VGND VGND VPWR VPWR sky130_fd_sc_hd__decap_3
XFILLER_24_586 VGND VGND VPWR VPWR sky130_fd_sc_hd__fill_2
XFILLER_51_372 VGND VGND VPWR VPWR sky130_fd_sc_hd__decap_3
XFILLER_11_236 VGND VGND VPWR VPWR sky130_fd_sc_hd__decap_3
XFILLER_109_113 VGND VGND VPWR VPWR sky130_fd_sc_hd__decap_3
Xclkload1 clkload1/A VGND VGND VPWR VPWR clkload1/X sky130_fd_sc_hd__clkbuf_16
XFILLER_109_146 VGND VGND VPWR VPWR sky130_fd_sc_hd__decap_3
XFILLER_119_3 VGND VGND VPWR VPWR sky130_fd_sc_hd__decap_3
XFILLER_50_78 VGND VGND VPWR VPWR sky130_fd_sc_hd__decap_3
XFILLER_105_352 VGND VGND VPWR VPWR sky130_fd_sc_hd__decap_3
XFILLER_66_409 VGND VGND VPWR VPWR sky130_fd_sc_hd__decap_3
XFILLER_94_707 VGND VGND VPWR VPWR sky130_fd_sc_hd__decap_3
XFILLER_115_60 VGND VGND VPWR VPWR sky130_fd_sc_hd__decap_3
XFILLER_47_601 VGND VGND VPWR VPWR sky130_fd_sc_hd__decap_3
XFILLER_47_623 VGND VGND VPWR VPWR sky130_fd_sc_hd__decap_3
XFILLER_59_461 VGND VGND VPWR VPWR sky130_fd_sc_hd__fill_2
XFILLER_93_228 VGND VGND VPWR VPWR sky130_fd_sc_hd__decap_3
XFILLER_101_580 VGND VGND VPWR VPWR sky130_fd_sc_hd__decap_3
XFILLER_115_93 VGND VGND VPWR VPWR sky130_fd_sc_hd__decap_3
XFILLER_47_656 VGND VGND VPWR VPWR sky130_fd_sc_hd__decap_3
XFILLER_86_291 VGND VGND VPWR VPWR sky130_fd_sc_hd__decap_3
XFILLER_74_475 VGND VGND VPWR VPWR sky130_fd_sc_hd__fill_1
XFILLER_46_177 VGND VGND VPWR VPWR sky130_fd_sc_hd__decap_3
XFILLER_61_125 VGND VGND VPWR VPWR sky130_fd_sc_hd__decap_3
XFILLER_62_626 VGND VGND VPWR VPWR sky130_fd_sc_hd__decap_3
XFILLER_62_648 VGND VGND VPWR VPWR sky130_fd_sc_hd__decap_3
XTAP_TAPCELL_ROW_45_824 VGND VPWR sky130_fd_sc_hd__tapvpwrvgnd_1
XFILLER_15_553 VGND VGND VPWR VPWR sky130_fd_sc_hd__decap_3
XFILLER_61_158 VGND VGND VPWR VPWR sky130_fd_sc_hd__decap_3
XFILLER_61_169 VGND VGND VPWR VPWR sky130_fd_sc_hd__decap_3
XFILLER_15_575 VGND VGND VPWR VPWR sky130_fd_sc_hd__decap_3
XFILLER_70_681 VGND VGND VPWR VPWR sky130_fd_sc_hd__decap_3
XFILLER_91_74 VGND VGND VPWR VPWR sky130_fd_sc_hd__decap_3
XFILLER_30_556 VGND VGND VPWR VPWR sky130_fd_sc_hd__fill_2
XFILLER_42_394 VGND VGND VPWR VPWR sky130_fd_sc_hd__decap_3
XTAP_TAPCELL_ROW_25_570 VGND VPWR sky130_fd_sc_hd__tapvpwrvgnd_1
XFILLER_30_567 VGND VGND VPWR VPWR sky130_fd_sc_hd__decap_3
XFILLER_30_589 VGND VGND VPWR VPWR sky130_fd_sc_hd__decap_3
XFILLER_116_628 VGND VGND VPWR VPWR sky130_fd_sc_hd__decap_3
XFILLER_6_251 VGND VGND VPWR VPWR sky130_fd_sc_hd__fill_1
Xhold708 _6935_/Q VGND VGND VPWR VPWR _6935_/D sky130_fd_sc_hd__dlygate4sd3_1
Xhold719 _6945_/Q VGND VGND VPWR VPWR _6945_/D sky130_fd_sc_hd__dlygate4sd3_1
Xwire672 _3576_/Y VGND VGND VPWR VPWR _3591_/B sky130_fd_sc_hd__clkbuf_2
XTAP_TAPCELL_ROW_77_1225 VGND VPWR sky130_fd_sc_hd__tapvpwrvgnd_1
XFILLER_109_691 VGND VGND VPWR VPWR sky130_fd_sc_hd__decap_3
XFILLER_6_273 VGND VGND VPWR VPWR sky130_fd_sc_hd__decap_3
XFILLER_97_501 VGND VGND VPWR VPWR sky130_fd_sc_hd__decap_3
XFILLER_111_311 VGND VGND VPWR VPWR sky130_fd_sc_hd__decap_3
XFILLER_34_3 VGND VGND VPWR VPWR sky130_fd_sc_hd__fill_1
XFILLER_69_225 VGND VGND VPWR VPWR sky130_fd_sc_hd__decap_3
X_5120_ _5120_/A _5120_/B VGND VGND VPWR VPWR _6984_/D sky130_fd_sc_hd__nor2_2
XFILLER_97_556 VGND VGND VPWR VPWR sky130_fd_sc_hd__decap_3
XFILLER_97_567 VGND VGND VPWR VPWR sky130_fd_sc_hd__decap_3
X_5051_ _5073_/A _5050_/X _5054_/A VGND VGND VPWR VPWR _5051_/X sky130_fd_sc_hd__a21o_2
XFILLER_38_601 VGND VGND VPWR VPWR sky130_fd_sc_hd__decap_3
XFILLER_84_206 VGND VGND VPWR VPWR sky130_fd_sc_hd__decap_3
XFILLER_37_111 VGND VGND VPWR VPWR sky130_fd_sc_hd__fill_1
XFILLER_38_634 VGND VGND VPWR VPWR sky130_fd_sc_hd__decap_3
XFILLER_38_645 VGND VGND VPWR VPWR sky130_fd_sc_hd__decap_3
XFILLER_84_239 VGND VGND VPWR VPWR sky130_fd_sc_hd__decap_3
XFILLER_38_678 VGND VGND VPWR VPWR sky130_fd_sc_hd__decap_3
XFILLER_53_615 VGND VGND VPWR VPWR sky130_fd_sc_hd__fill_1
XFILLER_65_464 VGND VGND VPWR VPWR sky130_fd_sc_hd__fill_2
XFILLER_80_401 VGND VGND VPWR VPWR sky130_fd_sc_hd__decap_3
XTAP_TAPCELL_ROW_88_1354 VGND VPWR sky130_fd_sc_hd__tapvpwrvgnd_1
XFILLER_111_18 VGND VGND VPWR VPWR sky130_fd_sc_hd__decap_3
XFILLER_18_380 VGND VGND VPWR VPWR sky130_fd_sc_hd__fill_2
XFILLER_25_317 VGND VGND VPWR VPWR sky130_fd_sc_hd__decap_3
XFILLER_37_188 VGND VGND VPWR VPWR sky130_fd_sc_hd__decap_3
XFILLER_53_626 VGND VGND VPWR VPWR sky130_fd_sc_hd__decap_3
XFILLER_65_497 VGND VGND VPWR VPWR sky130_fd_sc_hd__decap_3
XFILLER_53_659 VGND VGND VPWR VPWR sky130_fd_sc_hd__decap_3
XFILLER_80_445 VGND VGND VPWR VPWR sky130_fd_sc_hd__decap_3
XFILLER_21_501 VGND VGND VPWR VPWR sky130_fd_sc_hd__decap_3
XFILLER_40_309 VGND VGND VPWR VPWR sky130_fd_sc_hd__decap_3
XFILLER_80_489 VGND VGND VPWR VPWR sky130_fd_sc_hd__fill_1
X_4904_ _4903_/A _4904_/B VGND VGND VPWR VPWR _4904_/X sky130_fd_sc_hd__and2b_2
XFILLER_21_534 VGND VGND VPWR VPWR sky130_fd_sc_hd__fill_1
X_4835_ _4467_/B _3709_/X _4832_/X _4834_/Y VGND VGND VPWR VPWR _4835_/X sky130_fd_sc_hd__a31o_2
XFILLER_119_411 VGND VGND VPWR VPWR sky130_fd_sc_hd__decap_3
X_4766_ _4766_/A VGND VGND VPWR VPWR _4766_/Y sky130_fd_sc_hd__inv_2
XFILLER_119_455 VGND VGND VPWR VPWR sky130_fd_sc_hd__decap_3
X_6505_ _6640_/A VGND VGND VPWR VPWR _6505_/Y sky130_fd_sc_hd__inv_2
XFILLER_107_617 VGND VGND VPWR VPWR sky130_fd_sc_hd__decap_3
XFILLER_119_477 VGND VGND VPWR VPWR sky130_fd_sc_hd__decap_3
X_4697_ _5670_/A _6984_/Q _5670_/B VGND VGND VPWR VPWR _5120_/A sky130_fd_sc_hd__and3_2
XTAP_TAPCELL_ROW_99_1494 VGND VPWR sky130_fd_sc_hd__tapvpwrvgnd_1
XFILLER_105_9 VGND VGND VPWR VPWR sky130_fd_sc_hd__decap_3
XFILLER_106_116 VGND VGND VPWR VPWR sky130_fd_sc_hd__decap_3
X_6436_ _6627_/A VGND VGND VPWR VPWR _6436_/Y sky130_fd_sc_hd__inv_2
XFILLER_115_650 VGND VGND VPWR VPWR sky130_fd_sc_hd__decap_3
XFILLER_88_501 VGND VGND VPWR VPWR sky130_fd_sc_hd__decap_3
X_6367_ _6632_/A VGND VGND VPWR VPWR _6367_/Y sky130_fd_sc_hd__inv_2
X_3579_ _7220_/Q _4307_/A2 _3994_/S _7188_/Q VGND VGND VPWR VPWR _3579_/X sky130_fd_sc_hd__a22o_2
XFILLER_0_405 VGND VGND VPWR VPWR sky130_fd_sc_hd__decap_3
XFILLER_115_694 VGND VGND VPWR VPWR sky130_fd_sc_hd__decap_3
XFILLER_0_438 VGND VGND VPWR VPWR sky130_fd_sc_hd__decap_3
XFILLER_0_449 VGND VGND VPWR VPWR sky130_fd_sc_hd__decap_3
XFILLER_76_707 VGND VGND VPWR VPWR sky130_fd_sc_hd__decap_3
X_6298_ _6584_/A VGND VGND VPWR VPWR _6298_/Y sky130_fd_sc_hd__inv_2
XFILLER_102_388 VGND VGND VPWR VPWR sky130_fd_sc_hd__decap_3
XFILLER_29_46 VGND VGND VPWR VPWR sky130_fd_sc_hd__fill_2
XFILLER_29_57 VGND VGND VPWR VPWR sky130_fd_sc_hd__decap_3
XFILLER_29_612 VGND VGND VPWR VPWR sky130_fd_sc_hd__decap_3
XFILLER_75_217 VGND VGND VPWR VPWR sky130_fd_sc_hd__decap_3
XFILLER_88_578 VGND VGND VPWR VPWR sky130_fd_sc_hd__decap_3
XFILLER_88_589 VGND VGND VPWR VPWR sky130_fd_sc_hd__fill_2
X_5249_ _5249_/A0 _4878_/X _5272_/S VGND VGND VPWR VPWR _7205_/D sky130_fd_sc_hd__mux2_2
XFILLER_29_623 VGND VGND VPWR VPWR sky130_fd_sc_hd__decap_3
XFILLER_29_656 VGND VGND VPWR VPWR sky130_fd_sc_hd__decap_3
XFILLER_68_291 VGND VGND VPWR VPWR sky130_fd_sc_hd__decap_3
XFILLER_75_228 VGND VGND VPWR VPWR sky130_fd_sc_hd__decap_3
XFILLER_28_144 VGND VGND VPWR VPWR sky130_fd_sc_hd__decap_3
XFILLER_44_604 VGND VGND VPWR VPWR sky130_fd_sc_hd__decap_3
XFILLER_56_475 VGND VGND VPWR VPWR sky130_fd_sc_hd__fill_1
XFILLER_83_250 VGND VGND VPWR VPWR sky130_fd_sc_hd__fill_2
XFILLER_28_177 VGND VGND VPWR VPWR sky130_fd_sc_hd__decap_3
XFILLER_44_637 VGND VGND VPWR VPWR sky130_fd_sc_hd__decap_3
XFILLER_44_648 VGND VGND VPWR VPWR sky130_fd_sc_hd__decap_3
XFILLER_45_45 VGND VGND VPWR VPWR sky130_fd_sc_hd__decap_3
XFILLER_71_412 VGND VGND VPWR VPWR sky130_fd_sc_hd__decap_3
XFILLER_71_423 VGND VGND VPWR VPWR sky130_fd_sc_hd__decap_3
XFILLER_83_294 VGND VGND VPWR VPWR sky130_fd_sc_hd__decap_3
XTAP_TAPCELL_ROW_3_298 VGND VPWR sky130_fd_sc_hd__tapvpwrvgnd_1
XFILLER_45_78 VGND VGND VPWR VPWR sky130_fd_sc_hd__decap_3
XFILLER_24_350 VGND VGND VPWR VPWR sky130_fd_sc_hd__fill_1
XFILLER_24_361 VGND VGND VPWR VPWR sky130_fd_sc_hd__decap_3
XFILLER_43_169 VGND VGND VPWR VPWR sky130_fd_sc_hd__decap_3
XFILLER_52_681 VGND VGND VPWR VPWR sky130_fd_sc_hd__decap_3
XFILLER_101_84 VGND VGND VPWR VPWR sky130_fd_sc_hd__decap_3
XFILLER_24_383 VGND VGND VPWR VPWR sky130_fd_sc_hd__decap_3
XTAP_TAPCELL_ROW_61_1026 VGND VPWR sky130_fd_sc_hd__tapvpwrvgnd_1
XTAP_TAPCELL_ROW_61_1015 VGND VPWR sky130_fd_sc_hd__tapvpwrvgnd_1
XFILLER_12_578 VGND VGND VPWR VPWR sky130_fd_sc_hd__decap_3
XFILLER_12_589 VGND VGND VPWR VPWR sky130_fd_sc_hd__decap_3
XFILLER_61_55 VGND VGND VPWR VPWR sky130_fd_sc_hd__fill_1
XTAP_TAPCELL_ROW_50_882 VGND VPWR sky130_fd_sc_hd__tapvpwrvgnd_1
XFILLER_113_609 VGND VGND VPWR VPWR sky130_fd_sc_hd__decap_3
XFILLER_3_243 VGND VGND VPWR VPWR sky130_fd_sc_hd__decap_3
XFILLER_98_309 VGND VGND VPWR VPWR sky130_fd_sc_hd__decap_3
XFILLER_106_672 VGND VGND VPWR VPWR sky130_fd_sc_hd__decap_3
XFILLER_10_81 VGND VGND VPWR VPWR sky130_fd_sc_hd__decap_3
XFILLER_3_276 VGND VGND VPWR VPWR sky130_fd_sc_hd__decap_3
XFILLER_3_287 VGND VGND VPWR VPWR sky130_fd_sc_hd__decap_3
XFILLER_105_193 VGND VGND VPWR VPWR sky130_fd_sc_hd__decap_3
XTAP_TAPCELL_ROW_72_1155 VGND VPWR sky130_fd_sc_hd__tapvpwrvgnd_1
XFILLER_66_206 VGND VGND VPWR VPWR sky130_fd_sc_hd__decap_3
XFILLER_19_122 VGND VGND VPWR VPWR sky130_fd_sc_hd__fill_2
XFILLER_47_420 VGND VGND VPWR VPWR sky130_fd_sc_hd__fill_1
XFILLER_59_291 VGND VGND VPWR VPWR sky130_fd_sc_hd__decap_3
XFILLER_66_239 VGND VGND VPWR VPWR sky130_fd_sc_hd__decap_3
XFILLER_86_85 VGND VGND VPWR VPWR sky130_fd_sc_hd__decap_3
XFILLER_19_144 VGND VGND VPWR VPWR sky130_fd_sc_hd__decap_3
XFILLER_74_250 VGND VGND VPWR VPWR sky130_fd_sc_hd__fill_2
XFILLER_35_615 VGND VGND VPWR VPWR sky130_fd_sc_hd__fill_1
XFILLER_35_626 VGND VGND VPWR VPWR sky130_fd_sc_hd__decap_3
XFILLER_62_401 VGND VGND VPWR VPWR sky130_fd_sc_hd__decap_3
XFILLER_90_710 VGND VGND VPWR VPWR sky130_fd_sc_hd__decap_3
XTAP_TAPCELL_ROW_58_982 VGND VPWR sky130_fd_sc_hd__tapvpwrvgnd_1
XFILLER_34_136 VGND VGND VPWR VPWR sky130_fd_sc_hd__decap_3
XFILLER_35_659 VGND VGND VPWR VPWR sky130_fd_sc_hd__decap_3
XFILLER_62_445 VGND VGND VPWR VPWR sky130_fd_sc_hd__decap_3
XFILLER_22_309 VGND VGND VPWR VPWR sky130_fd_sc_hd__decap_3
XFILLER_50_629 VGND VGND VPWR VPWR sky130_fd_sc_hd__decap_3
XTAP_TAPCELL_ROW_83_1295 VGND VPWR sky130_fd_sc_hd__tapvpwrvgnd_1
XFILLER_30_342 VGND VGND VPWR VPWR sky130_fd_sc_hd__decap_3
X_4620_ _4620_/A _5003_/A _4987_/A _5032_/A VGND VGND VPWR VPWR _4624_/B sky130_fd_sc_hd__and4_4
XFILLER_30_397 VGND VGND VPWR VPWR sky130_fd_sc_hd__decap_3
XFILLER_116_403 VGND VGND VPWR VPWR sky130_fd_sc_hd__decap_3
XFILLER_7_582 VGND VGND VPWR VPWR sky130_fd_sc_hd__decap_3
X_7270_ _7374_/CLK _7270_/D _6550_/Y VGND VGND VPWR VPWR _7270_/Q sky130_fd_sc_hd__dfrtp_2
X_4482_ _4482_/A0 _4548_/A _4497_/S VGND VGND VPWR VPWR _7338_/D sky130_fd_sc_hd__mux2_2
X_3502_ _3502_/A _3502_/B _3485_/C VGND VGND VPWR VPWR _3502_/X sky130_fd_sc_hd__or3b_2
XFILLER_103_119 VGND VGND VPWR VPWR sky130_fd_sc_hd__decap_3
XFILLER_111_130 VGND VGND VPWR VPWR sky130_fd_sc_hd__decap_3
XFILLER_112_631 VGND VGND VPWR VPWR sky130_fd_sc_hd__decap_3
XFILLER_58_707 VGND VGND VPWR VPWR sky130_fd_sc_hd__decap_3
X_5103_ _5103_/A1 _5047_/Y _5099_/X _5102_/X VGND VGND VPWR VPWR _5660_/C sky130_fd_sc_hd__a31oi_2
X_3364_ _3362_/X _5294_/B _3371_/A VGND VGND VPWR VPWR _3399_/B sky130_fd_sc_hd__a21boi_2
XFILLER_112_675 VGND VGND VPWR VPWR sky130_fd_sc_hd__decap_3
XFILLER_57_206 VGND VGND VPWR VPWR sky130_fd_sc_hd__decap_3
Xhold1205 _7138_/Q VGND VGND VPWR VPWR _5390_/A0 sky130_fd_sc_hd__dlygate4sd3_1
Xhold1216 _7121_/Q VGND VGND VPWR VPWR _5425_/A0 sky130_fd_sc_hd__dlygate4sd3_1
XFILLER_111_185 VGND VGND VPWR VPWR sky130_fd_sc_hd__decap_3
XFILLER_57_228 VGND VGND VPWR VPWR sky130_fd_sc_hd__decap_3
Xhold1227 _7282_/Q VGND VGND VPWR VPWR _4597_/A0 sky130_fd_sc_hd__dlygate4sd3_1
Xhold1238 _7328_/Q VGND VGND VPWR VPWR _4503_/A0 sky130_fd_sc_hd__dlygate4sd3_1
Xhold1249 _3981_/X VGND VGND VPWR VPWR _7350_/D sky130_fd_sc_hd__dlygate4sd3_1
X_5034_ _4811_/C _5031_/X _5032_/Y _4969_/B _5033_/X VGND VGND VPWR VPWR _5658_/B
+ sky130_fd_sc_hd__a221o_2
XFILLER_26_604 VGND VGND VPWR VPWR sky130_fd_sc_hd__decap_3
XFILLER_72_209 VGND VGND VPWR VPWR sky130_fd_sc_hd__fill_2
XFILLER_26_637 VGND VGND VPWR VPWR sky130_fd_sc_hd__decap_3
XFILLER_26_648 VGND VGND VPWR VPWR sky130_fd_sc_hd__decap_3
XFILLER_65_261 VGND VGND VPWR VPWR sky130_fd_sc_hd__decap_3
XFILLER_65_272 VGND VGND VPWR VPWR sky130_fd_sc_hd__decap_3
XFILLER_25_125 VGND VGND VPWR VPWR sky130_fd_sc_hd__decap_3
XFILLER_25_147 VGND VGND VPWR VPWR sky130_fd_sc_hd__fill_1
XFILLER_53_445 VGND VGND VPWR VPWR sky130_fd_sc_hd__decap_3
XFILLER_65_294 VGND VGND VPWR VPWR sky130_fd_sc_hd__decap_3
XFILLER_80_231 VGND VGND VPWR VPWR sky130_fd_sc_hd__decap_3
X_6985_ _7390_/CLK _6985_/D _6265_/Y VGND VGND VPWR VPWR _6985_/Q sky130_fd_sc_hd__dfrtp_2
XTAP_TAPCELL_ROW_0_257 VGND VPWR sky130_fd_sc_hd__tapvpwrvgnd_1
XTAP_TAPCELL_ROW_0_246 VGND VPWR sky130_fd_sc_hd__tapvpwrvgnd_1
XFILLER_13_309 VGND VGND VPWR VPWR sky130_fd_sc_hd__decap_3
XFILLER_41_629 VGND VGND VPWR VPWR sky130_fd_sc_hd__decap_3
XFILLER_53_478 VGND VGND VPWR VPWR sky130_fd_sc_hd__fill_1
XFILLER_80_253 VGND VGND VPWR VPWR sky130_fd_sc_hd__decap_3
XFILLER_80_264 VGND VGND VPWR VPWR sky130_fd_sc_hd__decap_3
XFILLER_34_681 VGND VGND VPWR VPWR sky130_fd_sc_hd__decap_3
X_4818_ _7002_/Q _4834_/A VGND VGND VPWR VPWR _4818_/Y sky130_fd_sc_hd__nand2_2
XFILLER_5_508 VGND VGND VPWR VPWR sky130_fd_sc_hd__decap_3
X_4749_ _7006_/Q _4749_/B VGND VGND VPWR VPWR _4750_/C sky130_fd_sc_hd__nor2_2
XFILLER_103_6 VGND VGND VPWR VPWR sky130_fd_sc_hd__decap_3
XFILLER_107_458 VGND VGND VPWR VPWR sky130_fd_sc_hd__decap_3
X_6419_ _6654_/A VGND VGND VPWR VPWR _6419_/Y sky130_fd_sc_hd__inv_2
XFILLER_1_703 VGND VGND VPWR VPWR sky130_fd_sc_hd__decap_3
X_7399_ _7403_/CLK _7399_/D _6679_/Y VGND VGND VPWR VPWR _7399_/Q sky130_fd_sc_hd__dfrtp_2
XFILLER_0_213 VGND VGND VPWR VPWR sky130_fd_sc_hd__decap_3
XFILLER_0_246 VGND VGND VPWR VPWR sky130_fd_sc_hd__decap_3
XFILLER_103_620 VGND VGND VPWR VPWR sky130_fd_sc_hd__decap_3
XFILLER_103_653 VGND VGND VPWR VPWR sky130_fd_sc_hd__decap_3
XFILLER_115_491 VGND VGND VPWR VPWR sky130_fd_sc_hd__decap_3
XFILLER_88_320 VGND VGND VPWR VPWR sky130_fd_sc_hd__decap_3
XTAP_TAPCELL_ROW_8_357 VGND VPWR sky130_fd_sc_hd__tapvpwrvgnd_1
XFILLER_102_130 VGND VGND VPWR VPWR sky130_fd_sc_hd__decap_3
XFILLER_76_504 VGND VGND VPWR VPWR sky130_fd_sc_hd__fill_1
XFILLER_88_386 VGND VGND VPWR VPWR sky130_fd_sc_hd__decap_3
XFILLER_102_174 VGND VGND VPWR VPWR sky130_fd_sc_hd__decap_3
XFILLER_103_697 VGND VGND VPWR VPWR sky130_fd_sc_hd__decap_3
XFILLER_29_420 VGND VGND VPWR VPWR sky130_fd_sc_hd__decap_3
XFILLER_56_55 VGND VGND VPWR VPWR sky130_fd_sc_hd__decap_3
XFILLER_16_114 VGND VGND VPWR VPWR sky130_fd_sc_hd__decap_3
XFILLER_17_626 VGND VGND VPWR VPWR sky130_fd_sc_hd__decap_3
XFILLER_56_77 VGND VGND VPWR VPWR sky130_fd_sc_hd__decap_3
XFILLER_56_99 VGND VGND VPWR VPWR sky130_fd_sc_hd__fill_2
XFILLER_72_710 VGND VGND VPWR VPWR sky130_fd_sc_hd__decap_3
XFILLER_91_529 VGND VGND VPWR VPWR sky130_fd_sc_hd__decap_3
XFILLER_112_50 VGND VGND VPWR VPWR sky130_fd_sc_hd__decap_3
XFILLER_17_659 VGND VGND VPWR VPWR sky130_fd_sc_hd__decap_3
XFILLER_44_445 VGND VGND VPWR VPWR sky130_fd_sc_hd__decap_3
XFILLER_71_220 VGND VGND VPWR VPWR sky130_fd_sc_hd__decap_3
XFILLER_71_242 VGND VGND VPWR VPWR sky130_fd_sc_hd__decap_3
XTAP_TAPCELL_ROW_55_941 VGND VPWR sky130_fd_sc_hd__tapvpwrvgnd_1
XFILLER_112_83 VGND VGND VPWR VPWR sky130_fd_sc_hd__fill_1
XFILLER_32_607 VGND VGND VPWR VPWR sky130_fd_sc_hd__decap_3
XFILLER_44_489 VGND VGND VPWR VPWR sky130_fd_sc_hd__decap_3
XFILLER_72_32 VGND VGND VPWR VPWR sky130_fd_sc_hd__decap_3
XFILLER_24_180 VGND VGND VPWR VPWR sky130_fd_sc_hd__decap_3
XFILLER_12_342 VGND VGND VPWR VPWR sky130_fd_sc_hd__decap_3
XFILLER_40_640 VGND VGND VPWR VPWR sky130_fd_sc_hd__decap_3
XFILLER_40_651 VGND VGND VPWR VPWR sky130_fd_sc_hd__decap_3
XFILLER_8_302 VGND VGND VPWR VPWR sky130_fd_sc_hd__decap_3
XFILLER_40_684 VGND VGND VPWR VPWR sky130_fd_sc_hd__decap_3
XFILLER_8_324 VGND VGND VPWR VPWR sky130_fd_sc_hd__decap_3
XFILLER_68_9 VGND VGND VPWR VPWR sky130_fd_sc_hd__fill_2
XFILLER_4_530 VGND VGND VPWR VPWR sky130_fd_sc_hd__fill_2
XFILLER_113_428 VGND VGND VPWR VPWR sky130_fd_sc_hd__decap_3
XFILLER_4_563 VGND VGND VPWR VPWR sky130_fd_sc_hd__decap_3
XFILLER_98_117 VGND VGND VPWR VPWR sky130_fd_sc_hd__fill_1
XFILLER_99_629 VGND VGND VPWR VPWR sky130_fd_sc_hd__decap_3
XFILLER_106_491 VGND VGND VPWR VPWR sky130_fd_sc_hd__decap_3
XFILLER_4_596 VGND VGND VPWR VPWR sky130_fd_sc_hd__decap_3
XFILLER_97_51 VGND VGND VPWR VPWR sky130_fd_sc_hd__decap_3
XFILLER_39_217 VGND VGND VPWR VPWR sky130_fd_sc_hd__decap_3
XFILLER_39_228 VGND VGND VPWR VPWR sky130_fd_sc_hd__decap_3
XFILLER_67_526 VGND VGND VPWR VPWR sky130_fd_sc_hd__decap_3
XFILLER_67_548 VGND VGND VPWR VPWR sky130_fd_sc_hd__fill_1
XFILLER_94_312 VGND VGND VPWR VPWR sky130_fd_sc_hd__decap_3
XFILLER_54_209 VGND VGND VPWR VPWR sky130_fd_sc_hd__decap_3
XFILLER_82_507 VGND VGND VPWR VPWR sky130_fd_sc_hd__decap_3
XFILLER_94_378 VGND VGND VPWR VPWR sky130_fd_sc_hd__decap_3
XFILLER_75_592 VGND VGND VPWR VPWR sky130_fd_sc_hd__decap_3
XTAP_TAPCELL_ROW_85_1324 VGND VPWR sky130_fd_sc_hd__tapvpwrvgnd_1
XFILLER_22_106 VGND VGND VPWR VPWR sky130_fd_sc_hd__decap_3
XFILLER_23_629 VGND VGND VPWR VPWR sky130_fd_sc_hd__decap_3
XFILLER_35_489 VGND VGND VPWR VPWR sky130_fd_sc_hd__decap_3
XFILLER_50_415 VGND VGND VPWR VPWR sky130_fd_sc_hd__fill_1
X_6770_ _6968_/CLK _6770_/D VGND VGND VPWR VPWR _6770_/Q sky130_fd_sc_hd__dfxtp_2
XFILLER_16_681 VGND VGND VPWR VPWR sky130_fd_sc_hd__decap_3
XFILLER_22_128 VGND VGND VPWR VPWR sky130_fd_sc_hd__decap_3
X_5721_ _7366_/Q _5721_/A1 _5721_/S VGND VGND VPWR VPWR _6710_/D sky130_fd_sc_hd__mux2_2
XFILLER_31_662 VGND VGND VPWR VPWR sky130_fd_sc_hd__decap_3
XTAP_TAPCELL_ROW_33_668 VGND VPWR sky130_fd_sc_hd__tapvpwrvgnd_1
XFILLER_31_673 VGND VGND VPWR VPWR sky130_fd_sc_hd__decap_3
X_5652_ _5664_/A VGND VGND VPWR VPWR _5652_/Y sky130_fd_sc_hd__inv_2
XFILLER_117_712 VGND VGND VPWR VPWR sky130_fd_sc_hd__fill_2
X_5583_ _5583_/A0 _5094_/X _5595_/B VGND VGND VPWR VPWR _7037_/D sky130_fd_sc_hd__mux2_2
X_4603_ _4603_/A1 _4595_/B _3487_/X VGND VGND VPWR VPWR _7279_/D sky130_fd_sc_hd__a21o_2
XFILLER_116_200 VGND VGND VPWR VPWR sky130_fd_sc_hd__fill_1
X_7322_ _7322_/CLK _7322_/D _6602_/Y VGND VGND VPWR VPWR _7322_/Q sky130_fd_sc_hd__dfrtp_2
X_4534_ _4534_/A0 _4601_/A0 _4534_/S VGND VGND VPWR VPWR _7312_/D sky130_fd_sc_hd__mux2_2
XTAP_TAPCELL_ROW_96_1453 VGND VPWR sky130_fd_sc_hd__tapvpwrvgnd_1
XFILLER_117_17 VGND VGND VPWR VPWR sky130_fd_sc_hd__decap_3
XTAP_TAPCELL_ROW_96_1464 VGND VPWR sky130_fd_sc_hd__tapvpwrvgnd_1
XFILLER_89_106 VGND VGND VPWR VPWR sky130_fd_sc_hd__decap_3
XFILLER_89_128 VGND VGND VPWR VPWR sky130_fd_sc_hd__decap_3
X_7253_ _7345_/CLK _7253_/D _6533_/Y VGND VGND VPWR VPWR _7253_/Q sky130_fd_sc_hd__dfrtp_2
X_4465_ _5655_/B _5655_/C VGND VGND VPWR VPWR _5650_/A sky130_fd_sc_hd__nor2_2
XFILLER_98_651 VGND VGND VPWR VPWR sky130_fd_sc_hd__decap_3
X_7184_ _7387_/CLK _7184_/D _6464_/Y VGND VGND VPWR VPWR _7184_/Q sky130_fd_sc_hd__dfrtp_2
X_4396_ _4396_/A _4444_/B VGND VGND VPWR VPWR _4648_/A sky130_fd_sc_hd__nor2_2
XFILLER_98_684 VGND VGND VPWR VPWR sky130_fd_sc_hd__decap_3
X_3347_ _5640_/B _3509_/B VGND VGND VPWR VPWR _3420_/A sky130_fd_sc_hd__or2_2
XTAP_TAPCELL_ROW_5_316 VGND VPWR sky130_fd_sc_hd__tapvpwrvgnd_1
XFILLER_100_623 VGND VGND VPWR VPWR sky130_fd_sc_hd__decap_3
XFILLER_100_645 VGND VGND VPWR VPWR sky130_fd_sc_hd__decap_3
XFILLER_58_548 VGND VGND VPWR VPWR sky130_fd_sc_hd__decap_3
XFILLER_85_323 VGND VGND VPWR VPWR sky130_fd_sc_hd__fill_2
XFILLER_85_334 VGND VGND VPWR VPWR sky130_fd_sc_hd__fill_2
XFILLER_97_183 VGND VGND VPWR VPWR sky130_fd_sc_hd__decap_3
Xhold1002 _7088_/Q VGND VGND VPWR VPWR _7088_/D sky130_fd_sc_hd__dlygate4sd3_1
Xhold1013 _6714_/Q VGND VGND VPWR VPWR _5729_/A1 sky130_fd_sc_hd__dlygate4sd3_1
Xhold1024 _6717_/Q VGND VGND VPWR VPWR _5735_/A1 sky130_fd_sc_hd__dlygate4sd3_1
XFILLER_100_678 VGND VGND VPWR VPWR sky130_fd_sc_hd__decap_3
XFILLER_45_209 VGND VGND VPWR VPWR sky130_fd_sc_hd__decap_3
XFILLER_85_345 VGND VGND VPWR VPWR sky130_fd_sc_hd__decap_3
XFILLER_85_367 VGND VGND VPWR VPWR sky130_fd_sc_hd__decap_3
Xhold1035 _7042_/Q VGND VGND VPWR VPWR _5575_/A1 sky130_fd_sc_hd__dlygate4sd3_1
Xhold1046 _7046_/Q VGND VGND VPWR VPWR _5571_/A1 sky130_fd_sc_hd__dlygate4sd3_1
Xhold1057 _7044_/Q VGND VGND VPWR VPWR _5573_/A1 sky130_fd_sc_hd__dlygate4sd3_1
X_5017_ _5018_/A _5017_/B VGND VGND VPWR VPWR _5017_/Y sky130_fd_sc_hd__xnor2_2
XFILLER_54_710 VGND VGND VPWR VPWR sky130_fd_sc_hd__decap_3
Xhold1068 _7013_/Q VGND VGND VPWR VPWR _5630_/A sky130_fd_sc_hd__dlygate4sd3_1
Xhold1079 _7402_/Q VGND VGND VPWR VPWR _3698_/A1 sky130_fd_sc_hd__dlygate4sd3_1
XFILLER_26_434 VGND VGND VPWR VPWR sky130_fd_sc_hd__decap_3
XFILLER_53_231 VGND VGND VPWR VPWR sky130_fd_sc_hd__decap_3
XFILLER_66_592 VGND VGND VPWR VPWR sky130_fd_sc_hd__fill_1
XFILLER_14_607 VGND VGND VPWR VPWR sky130_fd_sc_hd__decap_3
XFILLER_26_489 VGND VGND VPWR VPWR sky130_fd_sc_hd__decap_3
XFILLER_53_264 VGND VGND VPWR VPWR sky130_fd_sc_hd__decap_3
XTAP_TAPCELL_ROW_52_911 VGND VPWR sky130_fd_sc_hd__tapvpwrvgnd_1
XFILLER_13_139 VGND VGND VPWR VPWR sky130_fd_sc_hd__decap_3
X_6968_ _6968_/CLK _6968_/D VGND VGND VPWR VPWR _6968_/Q sky130_fd_sc_hd__dfxtp_2
XTAP_TAPCELL_ROW_105_1571 VGND VPWR sky130_fd_sc_hd__tapvpwrvgnd_1
XFILLER_22_640 VGND VGND VPWR VPWR sky130_fd_sc_hd__decap_3
XFILLER_22_651 VGND VGND VPWR VPWR sky130_fd_sc_hd__decap_3
X_6899_ _7189_/CLK _6899_/D VGND VGND VPWR VPWR _6899_/Q sky130_fd_sc_hd__dfxtp_2
XFILLER_22_684 VGND VGND VPWR VPWR sky130_fd_sc_hd__decap_3
XFILLER_42_68 VGND VGND VPWR VPWR sky130_fd_sc_hd__decap_3
XFILLER_108_701 VGND VGND VPWR VPWR sky130_fd_sc_hd__decap_3
XFILLER_21_183 VGND VGND VPWR VPWR sky130_fd_sc_hd__decap_3
XFILLER_21_194 VGND VGND VPWR VPWR sky130_fd_sc_hd__decap_3
XFILLER_5_305 VGND VGND VPWR VPWR sky130_fd_sc_hd__decap_3
XFILLER_107_222 VGND VGND VPWR VPWR sky130_fd_sc_hd__fill_2
XFILLER_5_349 VGND VGND VPWR VPWR sky130_fd_sc_hd__decap_3
XFILLER_107_277 VGND VGND VPWR VPWR sky130_fd_sc_hd__decap_3
XFILLER_1_511 VGND VGND VPWR VPWR sky130_fd_sc_hd__decap_3
XFILLER_107_299 VGND VGND VPWR VPWR sky130_fd_sc_hd__decap_3
XFILLER_1_544 VGND VGND VPWR VPWR sky130_fd_sc_hd__decap_3
Xhold880 _6794_/Q VGND VGND VPWR VPWR _6794_/D sky130_fd_sc_hd__dlygate4sd3_1
Xhold891 _6857_/Q VGND VGND VPWR VPWR _6857_/D sky130_fd_sc_hd__dlygate4sd3_1
XFILLER_103_461 VGND VGND VPWR VPWR sky130_fd_sc_hd__decap_3
XFILLER_107_72 VGND VGND VPWR VPWR sky130_fd_sc_hd__decap_3
XFILLER_88_150 VGND VGND VPWR VPWR sky130_fd_sc_hd__decap_3
XFILLER_89_662 VGND VGND VPWR VPWR sky130_fd_sc_hd__decap_3
XFILLER_89_673 VGND VGND VPWR VPWR sky130_fd_sc_hd__decap_3
XFILLER_1_588 VGND VGND VPWR VPWR sky130_fd_sc_hd__decap_3
XFILLER_88_183 VGND VGND VPWR VPWR sky130_fd_sc_hd__decap_3
XFILLER_67_87 VGND VGND VPWR VPWR sky130_fd_sc_hd__decap_3
XFILLER_29_261 VGND VGND VPWR VPWR sky130_fd_sc_hd__decap_3
XFILLER_36_209 VGND VGND VPWR VPWR sky130_fd_sc_hd__decap_3
XFILLER_91_315 VGND VGND VPWR VPWR sky130_fd_sc_hd__decap_3
XFILLER_57_592 VGND VGND VPWR VPWR sky130_fd_sc_hd__fill_1
XFILLER_83_31 VGND VGND VPWR VPWR sky130_fd_sc_hd__fill_1
XFILLER_91_337 VGND VGND VPWR VPWR sky130_fd_sc_hd__decap_3
XPHY_EDGE_ROW_103_Left_223 VGND VGND VPWR VPWR sky130_fd_sc_hd__decap_3
XFILLER_32_415 VGND VGND VPWR VPWR sky130_fd_sc_hd__decap_3
XFILLER_44_264 VGND VGND VPWR VPWR sky130_fd_sc_hd__decap_3
XFILLER_60_713 VGND VGND VPWR VPWR sky130_fd_sc_hd__fill_1
XFILLER_83_75 VGND VGND VPWR VPWR sky130_fd_sc_hd__decap_3
XFILLER_32_437 VGND VGND VPWR VPWR sky130_fd_sc_hd__decap_3
XFILLER_32_448 VGND VGND VPWR VPWR sky130_fd_sc_hd__decap_3
XTAP_TAPCELL_ROW_67_1098 VGND VPWR sky130_fd_sc_hd__tapvpwrvgnd_1
XFILLER_13_662 VGND VGND VPWR VPWR sky130_fd_sc_hd__decap_3
XTAP_TAPCELL_ROW_80_1254 VGND VPWR sky130_fd_sc_hd__tapvpwrvgnd_1
XFILLER_9_600 VGND VGND VPWR VPWR sky130_fd_sc_hd__decap_3
XFILLER_13_673 VGND VGND VPWR VPWR sky130_fd_sc_hd__decap_3
XTAP_TAPCELL_ROW_30_638 VGND VPWR sky130_fd_sc_hd__tapvpwrvgnd_1
XTAP_TAPCELL_ROW_30_627 VGND VPWR sky130_fd_sc_hd__tapvpwrvgnd_1
XFILLER_9_644 VGND VGND VPWR VPWR sky130_fd_sc_hd__decap_3
XFILLER_40_492 VGND VGND VPWR VPWR sky130_fd_sc_hd__fill_1
XFILLER_8_165 VGND VGND VPWR VPWR sky130_fd_sc_hd__decap_3
XFILLER_9_688 VGND VGND VPWR VPWR sky130_fd_sc_hd__decap_3
XFILLER_114_704 VGND VGND VPWR VPWR sky130_fd_sc_hd__decap_3
XTAP_TAPCELL_ROW_10_384 VGND VPWR sky130_fd_sc_hd__tapvpwrvgnd_1
XPHY_EDGE_ROW_112_Left_232 VGND VGND VPWR VPWR sky130_fd_sc_hd__decap_3
XFILLER_113_214 VGND VGND VPWR VPWR sky130_fd_sc_hd__decap_3
XFILLER_99_415 VGND VGND VPWR VPWR sky130_fd_sc_hd__fill_1
X_4250_ _7101_/Q _4351_/A2 _4267_/B1 _7165_/Q VGND VGND VPWR VPWR _4250_/X sky130_fd_sc_hd__a22o_2
XFILLER_113_258 VGND VGND VPWR VPWR sky130_fd_sc_hd__decap_3
X_4181_ _7200_/Q _3966_/S _4181_/B1 _7392_/Q VGND VGND VPWR VPWR _4181_/X sky130_fd_sc_hd__a22o_2
XFILLER_67_301 VGND VGND VPWR VPWR sky130_fd_sc_hd__decap_3
XFILLER_67_312 VGND VGND VPWR VPWR sky130_fd_sc_hd__decap_3
XFILLER_79_172 VGND VGND VPWR VPWR sky130_fd_sc_hd__decap_3
XFILLER_95_610 VGND VGND VPWR VPWR sky130_fd_sc_hd__decap_3
XFILLER_95_632 VGND VGND VPWR VPWR sky130_fd_sc_hd__decap_3
XTAP_TAPCELL_ROW_91_1394 VGND VPWR sky130_fd_sc_hd__tapvpwrvgnd_1
XFILLER_94_153 VGND VGND VPWR VPWR sky130_fd_sc_hd__decap_3
XFILLER_95_665 VGND VGND VPWR VPWR sky130_fd_sc_hd__decap_3
XFILLER_95_676 VGND VGND VPWR VPWR sky130_fd_sc_hd__decap_3
XFILLER_36_710 VGND VGND VPWR VPWR sky130_fd_sc_hd__decap_3
XFILLER_48_570 VGND VGND VPWR VPWR sky130_fd_sc_hd__decap_3
XTAP_TAPCELL_ROW_38_738 VGND VPWR sky130_fd_sc_hd__tapvpwrvgnd_1
XTAP_TAPCELL_ROW_38_727 VGND VPWR sky130_fd_sc_hd__tapvpwrvgnd_1
XFILLER_35_231 VGND VGND VPWR VPWR sky130_fd_sc_hd__decap_3
XFILLER_48_592 VGND VGND VPWR VPWR sky130_fd_sc_hd__decap_3
XFILLER_94_197 VGND VGND VPWR VPWR sky130_fd_sc_hd__decap_3
Xplace540 _6667_/A VGND VGND VPWR VPWR _6664_/A sky130_fd_sc_hd__buf_2
X_6822_ clkload5/A _6822_/D VGND VGND VPWR VPWR _6822_/Q sky130_fd_sc_hd__dfxtp_2
XFILLER_50_212 VGND VGND VPWR VPWR sky130_fd_sc_hd__decap_3
Xplace551 _6612_/A VGND VGND VPWR VPWR _6639_/A sky130_fd_sc_hd__buf_2
Xplace562 _6632_/A VGND VGND VPWR VPWR _6625_/A sky130_fd_sc_hd__buf_2
XTAP_TAPCELL_ROW_18_484 VGND VPWR sky130_fd_sc_hd__tapvpwrvgnd_1
XFILLER_50_256 VGND VGND VPWR VPWR sky130_fd_sc_hd__decap_3
X_6753_ _6906_/CLK _6753_/D VGND VGND VPWR VPWR _6753_/Q sky130_fd_sc_hd__dfxtp_2
XFILLER_31_470 VGND VGND VPWR VPWR sky130_fd_sc_hd__decap_3
X_6684_ _6686_/A VGND VGND VPWR VPWR _6684_/Y sky130_fd_sc_hd__inv_2
X_3896_ _3880_/X _3885_/X _3895_/X _3991_/A VGND VGND VPWR VPWR _3896_/Y sky130_fd_sc_hd__o31ai_2
XFILLER_117_542 VGND VGND VPWR VPWR sky130_fd_sc_hd__fill_1
X_5566_ _5566_/A1 _4777_/A _4860_/Y VGND VGND VPWR VPWR _7051_/D sky130_fd_sc_hd__o21a_2
XFILLER_117_597 VGND VGND VPWR VPWR sky130_fd_sc_hd__decap_3
X_7305_ _7406_/CLK _7305_/D _6585_/Y VGND VGND VPWR VPWR _7305_/Q sky130_fd_sc_hd__dfrtp_2
X_4517_ _4517_/A0 _4583_/A _4517_/S VGND VGND VPWR VPWR _7321_/D sky130_fd_sc_hd__mux2_2
XFILLER_104_214 VGND VGND VPWR VPWR sky130_fd_sc_hd__decap_3
XFILLER_104_236 VGND VGND VPWR VPWR sky130_fd_sc_hd__decap_3
X_7236_ _7362_/CLK _7236_/D _6516_/Y VGND VGND VPWR VPWR _7236_/Q sky130_fd_sc_hd__dfrtp_2
X_4448_ _4444_/X _4447_/Y _4413_/A VGND VGND VPWR VPWR _4448_/X sky130_fd_sc_hd__o21a_2
XFILLER_77_109 VGND VGND VPWR VPWR sky130_fd_sc_hd__decap_3
XFILLER_86_632 VGND VGND VPWR VPWR sky130_fd_sc_hd__decap_3
X_7167_ _7362_/CLK _7167_/D _6447_/Y VGND VGND VPWR VPWR _7167_/Q sky130_fd_sc_hd__dfrtp_2
X_4379_ _4938_/B _4379_/B VGND VGND VPWR VPWR _4937_/A sky130_fd_sc_hd__or2_2
XFILLER_100_431 VGND VGND VPWR VPWR sky130_fd_sc_hd__decap_3
XFILLER_112_280 VGND VGND VPWR VPWR sky130_fd_sc_hd__fill_2
XFILLER_85_131 VGND VGND VPWR VPWR sky130_fd_sc_hd__decap_3
XFILLER_86_654 VGND VGND VPWR VPWR sky130_fd_sc_hd__decap_3
X_7098_ _7322_/CLK _7098_/D _6378_/Y VGND VGND VPWR VPWR _7098_/Q sky130_fd_sc_hd__dfrtp_2
XFILLER_100_475 VGND VGND VPWR VPWR sky130_fd_sc_hd__fill_1
XFILLER_37_57 VGND VGND VPWR VPWR sky130_fd_sc_hd__decap_3
XFILLER_73_326 VGND VGND VPWR VPWR sky130_fd_sc_hd__decap_3
XFILLER_85_164 VGND VGND VPWR VPWR sky130_fd_sc_hd__decap_3
XFILLER_85_186 VGND VGND VPWR VPWR sky130_fd_sc_hd__decap_3
XFILLER_86_687 VGND VGND VPWR VPWR sky130_fd_sc_hd__decap_3
XTAP_TAPCELL_ROW_107_1600 VGND VPWR sky130_fd_sc_hd__tapvpwrvgnd_1
XFILLER_37_79 VGND VGND VPWR VPWR sky130_fd_sc_hd__decap_3
XFILLER_73_337 VGND VGND VPWR VPWR sky130_fd_sc_hd__fill_2
XFILLER_26_253 VGND VGND VPWR VPWR sky130_fd_sc_hd__decap_3
XFILLER_42_713 VGND VGND VPWR VPWR sky130_fd_sc_hd__fill_1
XFILLER_54_551 VGND VGND VPWR VPWR sky130_fd_sc_hd__decap_3
XFILLER_14_415 VGND VGND VPWR VPWR sky130_fd_sc_hd__decap_3
XFILLER_26_275 VGND VGND VPWR VPWR sky130_fd_sc_hd__decap_3
XFILLER_41_223 VGND VGND VPWR VPWR sky130_fd_sc_hd__fill_1
XFILLER_53_34 VGND VGND VPWR VPWR sky130_fd_sc_hd__decap_3
XFILLER_54_584 VGND VGND VPWR VPWR sky130_fd_sc_hd__decap_3
XFILLER_14_448 VGND VGND VPWR VPWR sky130_fd_sc_hd__decap_3
XFILLER_10_610 VGND VGND VPWR VPWR sky130_fd_sc_hd__decap_3
XFILLER_10_643 VGND VGND VPWR VPWR sky130_fd_sc_hd__fill_1
XFILLER_10_654 VGND VGND VPWR VPWR sky130_fd_sc_hd__decap_3
XFILLER_108_520 VGND VGND VPWR VPWR sky130_fd_sc_hd__decap_3
XFILLER_10_687 VGND VGND VPWR VPWR sky130_fd_sc_hd__decap_3
XFILLER_5_113 VGND VGND VPWR VPWR sky130_fd_sc_hd__fill_1
XFILLER_6_625 VGND VGND VPWR VPWR sky130_fd_sc_hd__decap_3
XFILLER_6_669 VGND VGND VPWR VPWR sky130_fd_sc_hd__decap_3
XFILLER_118_71 VGND VGND VPWR VPWR sky130_fd_sc_hd__decap_3
XFILLER_1_330 VGND VGND VPWR VPWR sky130_fd_sc_hd__decap_3
XFILLER_96_407 VGND VGND VPWR VPWR sky130_fd_sc_hd__decap_3
XFILLER_77_632 VGND VGND VPWR VPWR sky130_fd_sc_hd__decap_3
XFILLER_78_97 VGND VGND VPWR VPWR sky130_fd_sc_hd__decap_3
XFILLER_89_492 VGND VGND VPWR VPWR sky130_fd_sc_hd__decap_3
XFILLER_96_429 VGND VGND VPWR VPWR sky130_fd_sc_hd__fill_2
XFILLER_1_396 VGND VGND VPWR VPWR sky130_fd_sc_hd__fill_1
XFILLER_76_131 VGND VGND VPWR VPWR sky130_fd_sc_hd__fill_2
XFILLER_77_665 VGND VGND VPWR VPWR sky130_fd_sc_hd__decap_3
XFILLER_18_710 VGND VGND VPWR VPWR sky130_fd_sc_hd__decap_3
XFILLER_64_304 VGND VGND VPWR VPWR sky130_fd_sc_hd__decap_3
XFILLER_64_315 VGND VGND VPWR VPWR sky130_fd_sc_hd__decap_3
XFILLER_77_676 VGND VGND VPWR VPWR sky130_fd_sc_hd__decap_3
XFILLER_91_101 VGND VGND VPWR VPWR sky130_fd_sc_hd__fill_2
XFILLER_92_613 VGND VGND VPWR VPWR sky130_fd_sc_hd__decap_3
XFILLER_94_41 VGND VGND VPWR VPWR sky130_fd_sc_hd__decap_3
XTAP_TAPCELL_ROW_69_1116 VGND VPWR sky130_fd_sc_hd__tapvpwrvgnd_1
XFILLER_17_220 VGND VGND VPWR VPWR sky130_fd_sc_hd__decap_3
XFILLER_64_359 VGND VGND VPWR VPWR sky130_fd_sc_hd__decap_3
XFILLER_76_186 VGND VGND VPWR VPWR sky130_fd_sc_hd__decap_3
XFILLER_91_145 VGND VGND VPWR VPWR sky130_fd_sc_hd__decap_3
XFILLER_92_657 VGND VGND VPWR VPWR sky130_fd_sc_hd__decap_3
XFILLER_94_85 VGND VGND VPWR VPWR sky130_fd_sc_hd__decap_3
XFILLER_91_178 VGND VGND VPWR VPWR sky130_fd_sc_hd__decap_3
XFILLER_60_521 VGND VGND VPWR VPWR sky130_fd_sc_hd__decap_3
XFILLER_32_256 VGND VGND VPWR VPWR sky130_fd_sc_hd__decap_3
XTAP_TAPCELL_ROW_15_443 VGND VPWR sky130_fd_sc_hd__tapvpwrvgnd_1
X_3750_ _3750_/A1 _3857_/A2 wire663/X VGND VGND VPWR VPWR _7398_/D sky130_fd_sc_hd__a21bo_2
XTAP_TAPCELL_ROW_43_796 VGND VPWR sky130_fd_sc_hd__tapvpwrvgnd_1
XFILLER_9_452 VGND VGND VPWR VPWR sky130_fd_sc_hd__decap_3
X_3681_ _3674_/Y _3926_/B1 _3760_/B1 _3676_/Y _3680_/X VGND VGND VPWR VPWR _3682_/B
+ sky130_fd_sc_hd__a221o_2
XFILLER_9_485 VGND VGND VPWR VPWR sky130_fd_sc_hd__fill_1
XFILLER_64_3 VGND VGND VPWR VPWR sky130_fd_sc_hd__fill_2
XFILLER_114_512 VGND VGND VPWR VPWR sky130_fd_sc_hd__decap_3
XTAP_TAPCELL_ROW_93_1423 VGND VPWR sky130_fd_sc_hd__tapvpwrvgnd_1
XFILLER_5_691 VGND VGND VPWR VPWR sky130_fd_sc_hd__decap_3
X_5282_ _5282_/A1 _5238_/X _3610_/Y VGND VGND VPWR VPWR _7189_/D sky130_fd_sc_hd__a21o_2
X_4302_ _7224_/Q _4349_/B1 _4347_/C1 _4301_/X VGND VGND VPWR VPWR _4302_/X sky130_fd_sc_hd__a211o_2
XFILLER_99_245 VGND VGND VPWR VPWR sky130_fd_sc_hd__decap_3
XFILLER_102_707 VGND VGND VPWR VPWR sky130_fd_sc_hd__decap_3
XFILLER_4_50 VGND VGND VPWR VPWR sky130_fd_sc_hd__decap_3
X_7021_ _7333_/CLK _7021_/D _6301_/Y VGND VGND VPWR VPWR _7021_/Q sky130_fd_sc_hd__dfrtp_2
X_4233_ _7323_/Q _3996_/S _4233_/B1 _7291_/Q VGND VGND VPWR VPWR _4233_/X sky130_fd_sc_hd__a22o_2
XFILLER_101_206 VGND VGND VPWR VPWR sky130_fd_sc_hd__decap_3
XFILLER_101_228 VGND VGND VPWR VPWR sky130_fd_sc_hd__fill_1
XFILLER_114_589 VGND VGND VPWR VPWR sky130_fd_sc_hd__decap_3
XFILLER_68_621 VGND VGND VPWR VPWR sky130_fd_sc_hd__decap_3
XFILLER_114_29 VGND VGND VPWR VPWR sky130_fd_sc_hd__decap_3
XFILLER_67_142 VGND VGND VPWR VPWR sky130_fd_sc_hd__decap_3
XFILLER_68_654 VGND VGND VPWR VPWR sky130_fd_sc_hd__decap_3
X_4164_ _7105_/Q _4417_/B1 _4267_/B1 _7169_/Q VGND VGND VPWR VPWR _4164_/X sky130_fd_sc_hd__a22o_2
XFILLER_67_164 VGND VGND VPWR VPWR sky130_fd_sc_hd__decap_3
XFILLER_68_687 VGND VGND VPWR VPWR sky130_fd_sc_hd__decap_3
X_4095_ _4095_/A _4210_/B VGND VGND VPWR VPWR _4096_/B sky130_fd_sc_hd__nand2_2
XFILLER_55_337 VGND VGND VPWR VPWR sky130_fd_sc_hd__decap_3
XFILLER_67_186 VGND VGND VPWR VPWR sky130_fd_sc_hd__decap_3
XFILLER_82_112 VGND VGND VPWR VPWR sky130_fd_sc_hd__decap_3
XFILLER_83_635 VGND VGND VPWR VPWR sky130_fd_sc_hd__decap_3
XFILLER_83_668 VGND VGND VPWR VPWR sky130_fd_sc_hd__decap_3
XFILLER_24_713 VGND VGND VPWR VPWR sky130_fd_sc_hd__fill_1
XFILLER_82_156 VGND VGND VPWR VPWR sky130_fd_sc_hd__decap_3
XFILLER_83_679 VGND VGND VPWR VPWR sky130_fd_sc_hd__decap_3
XFILLER_23_212 VGND VGND VPWR VPWR sky130_fd_sc_hd__decap_3
XFILLER_36_595 VGND VGND VPWR VPWR sky130_fd_sc_hd__decap_3
XFILLER_51_532 VGND VGND VPWR VPWR sky130_fd_sc_hd__fill_1
XFILLER_82_189 VGND VGND VPWR VPWR sky130_fd_sc_hd__fill_1
XFILLER_23_245 VGND VGND VPWR VPWR sky130_fd_sc_hd__decap_3
Xplace381 _3590_/A VGND VGND VPWR VPWR _4460_/A sky130_fd_sc_hd__buf_2
Xplace370 _5272_/S VGND VGND VPWR VPWR _5274_/S sky130_fd_sc_hd__buf_2
X_6805_ _6941_/CLK _6805_/D VGND VGND VPWR VPWR _6805_/Q sky130_fd_sc_hd__dfxtp_2
XTAP_TAPCELL_ROW_102_1530 VGND VPWR sky130_fd_sc_hd__tapvpwrvgnd_1
Xplace392 _3377_/X VGND VGND VPWR VPWR _4349_/B1 sky130_fd_sc_hd__buf_2
X_6736_ clkload4/A _6736_/D VGND VGND VPWR VPWR _6736_/Q sky130_fd_sc_hd__dfxtp_2
X_4997_ _4606_/A _6992_/D _4983_/X _4996_/X VGND VGND VPWR VPWR _4997_/X sky130_fd_sc_hd__a211o_2
X_6667_ _6667_/A VGND VGND VPWR VPWR _6667_/Y sky130_fd_sc_hd__inv_2
X_3879_ _6747_/Q _3892_/A2 _3879_/B1 _6735_/Q _3878_/X VGND VGND VPWR VPWR _3879_/X
+ sky130_fd_sc_hd__a221o_2
X_6598_ _6598_/A VGND VGND VPWR VPWR _6598_/Y sky130_fd_sc_hd__inv_2
XFILLER_105_501 VGND VGND VPWR VPWR sky130_fd_sc_hd__decap_3
XFILLER_3_617 VGND VGND VPWR VPWR sky130_fd_sc_hd__decap_3
XFILLER_105_534 VGND VGND VPWR VPWR sky130_fd_sc_hd__decap_3
XFILLER_105_567 VGND VGND VPWR VPWR sky130_fd_sc_hd__decap_3
XFILLER_59_632 VGND VGND VPWR VPWR sky130_fd_sc_hd__decap_3
X_7219_ _7350_/CLK _7219_/D _6499_/Y VGND VGND VPWR VPWR _7219_/Q sky130_fd_sc_hd__dfrtp_2
XTAP_TAPCELL_ROW_113_1670 VGND VPWR sky130_fd_sc_hd__tapvpwrvgnd_1
XFILLER_48_67 VGND VGND VPWR VPWR sky130_fd_sc_hd__decap_3
XFILLER_58_131 VGND VGND VPWR VPWR sky130_fd_sc_hd__decap_3
XFILLER_59_665 VGND VGND VPWR VPWR sky130_fd_sc_hd__decap_3
XFILLER_86_451 VGND VGND VPWR VPWR sky130_fd_sc_hd__decap_3
XFILLER_58_153 VGND VGND VPWR VPWR sky130_fd_sc_hd__decap_3
XFILLER_59_676 VGND VGND VPWR VPWR sky130_fd_sc_hd__decap_3
XFILLER_74_624 VGND VGND VPWR VPWR sky130_fd_sc_hd__decap_3
XFILLER_0_19 VGND VGND VPWR VPWR sky130_fd_sc_hd__fill_1
XFILLER_46_326 VGND VGND VPWR VPWR sky130_fd_sc_hd__decap_3
XFILLER_58_197 VGND VGND VPWR VPWR sky130_fd_sc_hd__decap_3
XFILLER_74_657 VGND VGND VPWR VPWR sky130_fd_sc_hd__decap_3
XFILLER_64_22 VGND VGND VPWR VPWR sky130_fd_sc_hd__decap_3
XFILLER_14_212 VGND VGND VPWR VPWR sky130_fd_sc_hd__decap_3
XFILLER_42_521 VGND VGND VPWR VPWR sky130_fd_sc_hd__decap_3
XFILLER_82_690 VGND VGND VPWR VPWR sky130_fd_sc_hd__decap_3
XFILLER_14_245 VGND VGND VPWR VPWR sky130_fd_sc_hd__fill_2
XFILLER_14_256 VGND VGND VPWR VPWR sky130_fd_sc_hd__decap_3
XTAP_TAPCELL_ROW_64_1057 VGND VPWR sky130_fd_sc_hd__tapvpwrvgnd_1
XFILLER_14_289 VGND VGND VPWR VPWR sky130_fd_sc_hd__decap_3
XFILLER_80_32 VGND VGND VPWR VPWR sky130_fd_sc_hd__decap_3
XTAP_TAPCELL_ROW_12_402 VGND VPWR sky130_fd_sc_hd__tapvpwrvgnd_1
XTAP_TAPCELL_ROW_12_413 VGND VPWR sky130_fd_sc_hd__tapvpwrvgnd_1
XFILLER_80_76 VGND VGND VPWR VPWR sky130_fd_sc_hd__decap_3
XTAP_TAPCELL_ROW_40_755 VGND VPWR sky130_fd_sc_hd__tapvpwrvgnd_1
XFILLER_6_444 VGND VGND VPWR VPWR sky130_fd_sc_hd__decap_3
XFILLER_89_85 VGND VGND VPWR VPWR sky130_fd_sc_hd__decap_3
XFILLER_2_672 VGND VGND VPWR VPWR sky130_fd_sc_hd__decap_3
XTAP_TAPCELL_ROW_75_1197 VGND VPWR sky130_fd_sc_hd__tapvpwrvgnd_1
XFILLER_111_548 VGND VGND VPWR VPWR sky130_fd_sc_hd__decap_3
XFILLER_37_304 VGND VGND VPWR VPWR sky130_fd_sc_hd__decap_3
XFILLER_37_337 VGND VGND VPWR VPWR sky130_fd_sc_hd__decap_3
XFILLER_49_186 VGND VGND VPWR VPWR sky130_fd_sc_hd__decap_3
XFILLER_65_635 VGND VGND VPWR VPWR sky130_fd_sc_hd__decap_3
XFILLER_92_432 VGND VGND VPWR VPWR sky130_fd_sc_hd__decap_3
XFILLER_52_307 VGND VGND VPWR VPWR sky130_fd_sc_hd__fill_1
XFILLER_64_156 VGND VGND VPWR VPWR sky130_fd_sc_hd__decap_3
XFILLER_65_668 VGND VGND VPWR VPWR sky130_fd_sc_hd__decap_3
XFILLER_65_679 VGND VGND VPWR VPWR sky130_fd_sc_hd__decap_3
XTAP_TAPCELL_ROW_48_855 VGND VPWR sky130_fd_sc_hd__tapvpwrvgnd_1
XFILLER_18_595 VGND VGND VPWR VPWR sky130_fd_sc_hd__decap_3
XFILLER_45_381 VGND VGND VPWR VPWR sky130_fd_sc_hd__decap_3
XFILLER_52_318 VGND VGND VPWR VPWR sky130_fd_sc_hd__decap_3
XFILLER_64_189 VGND VGND VPWR VPWR sky130_fd_sc_hd__decap_3
XFILLER_80_627 VGND VGND VPWR VPWR sky130_fd_sc_hd__decap_3
XFILLER_92_498 VGND VGND VPWR VPWR sky130_fd_sc_hd__decap_3
X_4920_ _4920_/A _4920_/B VGND VGND VPWR VPWR _4920_/Y sky130_fd_sc_hd__xnor2_2
X_4851_ _4633_/A _4142_/X _4849_/Y _4850_/Y _4969_/B VGND VGND VPWR VPWR _4855_/B
+ sky130_fd_sc_hd__o311a_2
X_3802_ _3733_/X _3794_/X _3796_/X _3746_/X _3801_/X VGND VGND VPWR VPWR _3802_/X
+ sky130_fd_sc_hd__a221o_2
XFILLER_20_226 VGND VGND VPWR VPWR sky130_fd_sc_hd__decap_3
X_4782_ _4413_/A _4444_/X _4780_/Y _4969_/B VGND VGND VPWR VPWR _4782_/Y sky130_fd_sc_hd__o31ai_2
XFILLER_118_103 VGND VGND VPWR VPWR sky130_fd_sc_hd__decap_3
XFILLER_119_626 VGND VGND VPWR VPWR sky130_fd_sc_hd__decap_3
X_6521_ _6617_/A VGND VGND VPWR VPWR _6521_/Y sky130_fd_sc_hd__inv_2
X_3733_ _3746_/A _3741_/B _3733_/C VGND VGND VPWR VPWR _3733_/X sky130_fd_sc_hd__and3_2
XFILLER_109_18 VGND VGND VPWR VPWR sky130_fd_sc_hd__decap_3
XFILLER_118_147 VGND VGND VPWR VPWR sky130_fd_sc_hd__decap_3
XFILLER_119_648 VGND VGND VPWR VPWR sky130_fd_sc_hd__decap_3
X_6452_ _6644_/A VGND VGND VPWR VPWR _6452_/Y sky130_fd_sc_hd__inv_2
XFILLER_9_293 VGND VGND VPWR VPWR sky130_fd_sc_hd__decap_3
XFILLER_106_309 VGND VGND VPWR VPWR sky130_fd_sc_hd__decap_3
Xclkload30 _7333_/CLK VGND VGND VPWR VPWR clkload30/Y sky130_fd_sc_hd__clkinv_2
X_6383_ _6639_/A VGND VGND VPWR VPWR _6383_/Y sky130_fd_sc_hd__inv_2
X_3595_ _4292_/A _3594_/B _3594_/Y _5020_/A VGND VGND VPWR VPWR _3614_/A sky130_fd_sc_hd__a211o_2
XFILLER_114_375 VGND VGND VPWR VPWR sky130_fd_sc_hd__fill_2
XFILLER_87_237 VGND VGND VPWR VPWR sky130_fd_sc_hd__decap_3
X_7004_ _7373_/CLK _7004_/D _6284_/Y VGND VGND VPWR VPWR _7004_/Q sky130_fd_sc_hd__dfrtp_2
X_5196_ _5196_/A _5207_/B VGND VGND VPWR VPWR _7230_/D sky130_fd_sc_hd__and2_2
X_4216_ _7068_/Q _4265_/B _4460_/A VGND VGND VPWR VPWR _4371_/B sky130_fd_sc_hd__o21a_2
XFILLER_56_613 VGND VGND VPWR VPWR sky130_fd_sc_hd__decap_3
XFILLER_68_451 VGND VGND VPWR VPWR sky130_fd_sc_hd__decap_3
X_4147_ _7266_/Q _4422_/A2 _3964_/S _7330_/Q _4146_/X VGND VGND VPWR VPWR _4147_/X
+ sky130_fd_sc_hd__a221o_2
XFILLER_110_581 VGND VGND VPWR VPWR sky130_fd_sc_hd__decap_3
XFILLER_110_592 VGND VGND VPWR VPWR sky130_fd_sc_hd__decap_3
XFILLER_56_657 VGND VGND VPWR VPWR sky130_fd_sc_hd__decap_3
XFILLER_95_270 VGND VGND VPWR VPWR sky130_fd_sc_hd__decap_3
XFILLER_95_292 VGND VGND VPWR VPWR sky130_fd_sc_hd__fill_2
XFILLER_28_359 VGND VGND VPWR VPWR sky130_fd_sc_hd__decap_3
XFILLER_55_145 VGND VGND VPWR VPWR sky130_fd_sc_hd__decap_3
XFILLER_55_156 VGND VGND VPWR VPWR sky130_fd_sc_hd__decap_3
XFILLER_83_476 VGND VGND VPWR VPWR sky130_fd_sc_hd__decap_3
X_4078_ _7025_/Q _4437_/A2 _4394_/B _7371_/Q VGND VGND VPWR VPWR _4078_/X sky130_fd_sc_hd__a22o_2
XFILLER_55_178 VGND VGND VPWR VPWR sky130_fd_sc_hd__decap_3
XFILLER_64_690 VGND VGND VPWR VPWR sky130_fd_sc_hd__decap_3
XFILLER_71_638 VGND VGND VPWR VPWR sky130_fd_sc_hd__decap_3
XFILLER_34_58 VGND VGND VPWR VPWR sky130_fd_sc_hd__decap_3
XFILLER_11_248 VGND VGND VPWR VPWR sky130_fd_sc_hd__decap_3
XFILLER_24_598 VGND VGND VPWR VPWR sky130_fd_sc_hd__decap_3
XFILLER_109_103 VGND VGND VPWR VPWR sky130_fd_sc_hd__decap_3
Xclkload2 clkload2/A VGND VGND VPWR VPWR clkload2/X sky130_fd_sc_hd__clkbuf_16
X_6719_ clkload3/A _6719_/D VGND VGND VPWR VPWR _6719_/Q sky130_fd_sc_hd__dfxtp_2
XFILLER_109_125 VGND VGND VPWR VPWR sky130_fd_sc_hd__fill_2
XFILLER_109_158 VGND VGND VPWR VPWR sky130_fd_sc_hd__decap_3
XFILLER_109_169 VGND VGND VPWR VPWR sky130_fd_sc_hd__decap_3
XFILLER_118_681 VGND VGND VPWR VPWR sky130_fd_sc_hd__decap_3
XFILLER_3_414 VGND VGND VPWR VPWR sky130_fd_sc_hd__decap_3
XFILLER_3_436 VGND VGND VPWR VPWR sky130_fd_sc_hd__decap_3
XFILLER_105_331 VGND VGND VPWR VPWR sky130_fd_sc_hd__fill_1
XFILLER_3_469 VGND VGND VPWR VPWR sky130_fd_sc_hd__fill_1
XFILLER_105_364 VGND VGND VPWR VPWR sky130_fd_sc_hd__decap_3
XFILLER_105_386 VGND VGND VPWR VPWR sky130_fd_sc_hd__decap_3
XFILLER_59_77 VGND VGND VPWR VPWR sky130_fd_sc_hd__decap_3
XFILLER_78_204 VGND VGND VPWR VPWR sky130_fd_sc_hd__decap_3
XFILLER_78_215 VGND VGND VPWR VPWR sky130_fd_sc_hd__decap_3
Xoutput590 _5656_/A VGND VGND VPWR VPWR alu_result_out[26] sky130_fd_sc_hd__clkdlybuf4s25_1
XFILLER_78_248 VGND VGND VPWR VPWR sky130_fd_sc_hd__decap_3
XFILLER_78_259 VGND VGND VPWR VPWR sky130_fd_sc_hd__decap_3
XFILLER_115_72 VGND VGND VPWR VPWR sky130_fd_sc_hd__decap_3
XFILLER_19_304 VGND VGND VPWR VPWR sky130_fd_sc_hd__fill_2
XFILLER_47_613 VGND VGND VPWR VPWR sky130_fd_sc_hd__decap_3
XFILLER_19_337 VGND VGND VPWR VPWR sky130_fd_sc_hd__decap_3
XFILLER_19_348 VGND VGND VPWR VPWR sky130_fd_sc_hd__decap_3
XFILLER_47_635 VGND VGND VPWR VPWR sky130_fd_sc_hd__decap_3
XFILLER_59_484 VGND VGND VPWR VPWR sky130_fd_sc_hd__decap_3
XFILLER_34_307 VGND VGND VPWR VPWR sky130_fd_sc_hd__fill_1
XFILLER_46_156 VGND VGND VPWR VPWR sky130_fd_sc_hd__decap_3
XFILLER_47_668 VGND VGND VPWR VPWR sky130_fd_sc_hd__decap_3
XFILLER_47_679 VGND VGND VPWR VPWR sky130_fd_sc_hd__decap_3
XFILLER_75_76 VGND VGND VPWR VPWR sky130_fd_sc_hd__fill_1
XFILLER_75_87 VGND VGND VPWR VPWR sky130_fd_sc_hd__decap_3
XFILLER_46_189 VGND VGND VPWR VPWR sky130_fd_sc_hd__decap_3
XFILLER_61_104 VGND VGND VPWR VPWR sky130_fd_sc_hd__decap_3
XFILLER_62_638 VGND VGND VPWR VPWR sky130_fd_sc_hd__decap_3
XTAP_TAPCELL_ROW_45_825 VGND VPWR sky130_fd_sc_hd__tapvpwrvgnd_1
XFILLER_61_137 VGND VGND VPWR VPWR sky130_fd_sc_hd__decap_3
XFILLER_91_31 VGND VGND VPWR VPWR sky130_fd_sc_hd__decap_3
XFILLER_15_587 VGND VGND VPWR VPWR sky130_fd_sc_hd__decap_3
XFILLER_42_373 VGND VGND VPWR VPWR sky130_fd_sc_hd__decap_3
XFILLER_70_660 VGND VGND VPWR VPWR sky130_fd_sc_hd__decap_3
XFILLER_70_693 VGND VGND VPWR VPWR sky130_fd_sc_hd__decap_3
XFILLER_91_86 VGND VGND VPWR VPWR sky130_fd_sc_hd__decap_3
XTAP_TAPCELL_ROW_25_571 VGND VPWR sky130_fd_sc_hd__tapvpwrvgnd_1
XFILLER_30_579 VGND VGND VPWR VPWR sky130_fd_sc_hd__decap_3
XFILLER_116_607 VGND VGND VPWR VPWR sky130_fd_sc_hd__decap_3
XFILLER_6_230 VGND VGND VPWR VPWR sky130_fd_sc_hd__decap_3
Xhold709 _6931_/Q VGND VGND VPWR VPWR _6931_/D sky130_fd_sc_hd__dlygate4sd3_1
XTAP_TAPCELL_ROW_77_1226 VGND VPWR sky130_fd_sc_hd__tapvpwrvgnd_1
XTAP_TAPCELL_ROW_77_1215 VGND VPWR sky130_fd_sc_hd__tapvpwrvgnd_1
XFILLER_6_285 VGND VGND VPWR VPWR sky130_fd_sc_hd__decap_3
X_3380_ _3528_/A _5118_/D VGND VGND VPWR VPWR _3380_/Y sky130_fd_sc_hd__nor2_2
XFILLER_69_204 VGND VGND VPWR VPWR sky130_fd_sc_hd__decap_3
XFILLER_97_513 VGND VGND VPWR VPWR sky130_fd_sc_hd__fill_1
XFILLER_97_535 VGND VGND VPWR VPWR sky130_fd_sc_hd__decap_3
XFILLER_111_334 VGND VGND VPWR VPWR sky130_fd_sc_hd__fill_2
XFILLER_2_480 VGND VGND VPWR VPWR sky130_fd_sc_hd__decap_3
XFILLER_69_248 VGND VGND VPWR VPWR sky130_fd_sc_hd__decap_3
X_5050_ _4619_/A _5101_/B _5100_/B _4366_/X VGND VGND VPWR VPWR _5050_/X sky130_fd_sc_hd__a31o_2
XFILLER_111_356 VGND VGND VPWR VPWR sky130_fd_sc_hd__decap_3
XFILLER_111_378 VGND VGND VPWR VPWR sky130_fd_sc_hd__decap_3
XFILLER_38_613 VGND VGND VPWR VPWR sky130_fd_sc_hd__decap_3
XFILLER_84_218 VGND VGND VPWR VPWR sky130_fd_sc_hd__decap_3
XFILLER_97_579 VGND VGND VPWR VPWR sky130_fd_sc_hd__decap_3
XFILLER_77_281 VGND VGND VPWR VPWR sky130_fd_sc_hd__fill_2
XFILLER_38_657 VGND VGND VPWR VPWR sky130_fd_sc_hd__decap_3
XTAP_TAPCELL_ROW_88_1355 VGND VPWR sky130_fd_sc_hd__tapvpwrvgnd_1
XFILLER_53_638 VGND VGND VPWR VPWR sky130_fd_sc_hd__decap_3
XFILLER_65_476 VGND VGND VPWR VPWR sky130_fd_sc_hd__decap_3
XFILLER_80_413 VGND VGND VPWR VPWR sky130_fd_sc_hd__decap_3
XFILLER_18_392 VGND VGND VPWR VPWR sky130_fd_sc_hd__decap_3
XFILLER_46_690 VGND VGND VPWR VPWR sky130_fd_sc_hd__decap_3
XFILLER_52_126 VGND VGND VPWR VPWR sky130_fd_sc_hd__decap_3
XFILLER_52_159 VGND VGND VPWR VPWR sky130_fd_sc_hd__decap_3
XFILLER_80_457 VGND VGND VPWR VPWR sky130_fd_sc_hd__decap_3
X_4903_ _4903_/A _4903_/B _4903_/C VGND VGND VPWR VPWR _4903_/X sky130_fd_sc_hd__and3_2
XFILLER_61_671 VGND VGND VPWR VPWR sky130_fd_sc_hd__fill_1
XFILLER_61_682 VGND VGND VPWR VPWR sky130_fd_sc_hd__decap_3
XFILLER_60_170 VGND VGND VPWR VPWR sky130_fd_sc_hd__decap_3
X_4834_ _4834_/A _4834_/B VGND VGND VPWR VPWR _4834_/Y sky130_fd_sc_hd__nor2_2
X_4765_ _4765_/A _4765_/B VGND VGND VPWR VPWR _4766_/A sky130_fd_sc_hd__and2_2
X_6504_ _6631_/A VGND VGND VPWR VPWR _6504_/Y sky130_fd_sc_hd__inv_2
XFILLER_107_607 VGND VGND VPWR VPWR sky130_fd_sc_hd__decap_3
XFILLER_107_629 VGND VGND VPWR VPWR sky130_fd_sc_hd__decap_3
X_4696_ _5118_/C _4696_/B VGND VGND VPWR VPWR _5670_/B sky130_fd_sc_hd__nor2_2
XTAP_TAPCELL_ROW_99_1495 VGND VPWR sky130_fd_sc_hd__tapvpwrvgnd_1
XFILLER_106_128 VGND VGND VPWR VPWR sky130_fd_sc_hd__decap_3
XFILLER_20_27 VGND VGND VPWR VPWR sky130_fd_sc_hd__fill_1
X_6435_ _6627_/A VGND VGND VPWR VPWR _6435_/Y sky130_fd_sc_hd__inv_2
XFILLER_115_662 VGND VGND VPWR VPWR sky130_fd_sc_hd__decap_3
X_6366_ _6649_/A VGND VGND VPWR VPWR _6366_/Y sky130_fd_sc_hd__inv_2
X_3578_ _7284_/Q _4335_/A2 _3417_/X _7092_/Q VGND VGND VPWR VPWR _3583_/A sky130_fd_sc_hd__a22o_2
XFILLER_0_417 VGND VGND VPWR VPWR sky130_fd_sc_hd__decap_3
XFILLER_102_312 VGND VGND VPWR VPWR sky130_fd_sc_hd__decap_3
XFILLER_115_673 VGND VGND VPWR VPWR sky130_fd_sc_hd__decap_3
XFILLER_88_524 VGND VGND VPWR VPWR sky130_fd_sc_hd__decap_3
X_5317_ _5317_/A0 _4899_/X _5340_/S VGND VGND VPWR VPWR _7172_/D sky130_fd_sc_hd__mux2_2
XFILLER_102_345 VGND VGND VPWR VPWR sky130_fd_sc_hd__decap_3
X_6297_ _6612_/A VGND VGND VPWR VPWR _6297_/Y sky130_fd_sc_hd__inv_2
XFILLER_28_101 VGND VGND VPWR VPWR sky130_fd_sc_hd__decap_3
XFILLER_29_635 VGND VGND VPWR VPWR sky130_fd_sc_hd__decap_3
XFILLER_56_410 VGND VGND VPWR VPWR sky130_fd_sc_hd__decap_3
XFILLER_56_421 VGND VGND VPWR VPWR sky130_fd_sc_hd__decap_3
X_5179_ _5179_/A _5207_/B VGND VGND VPWR VPWR _7238_/D sky130_fd_sc_hd__and2_2
XFILLER_28_134 VGND VGND VPWR VPWR sky130_fd_sc_hd__decap_3
XFILLER_28_156 VGND VGND VPWR VPWR sky130_fd_sc_hd__decap_3
XFILLER_29_668 VGND VGND VPWR VPWR sky130_fd_sc_hd__decap_3
XFILLER_29_679 VGND VGND VPWR VPWR sky130_fd_sc_hd__decap_3
XFILLER_44_616 VGND VGND VPWR VPWR sky130_fd_sc_hd__decap_3
XFILLER_83_284 VGND VGND VPWR VPWR sky130_fd_sc_hd__decap_3
XTAP_TAPCELL_ROW_3_299 VGND VPWR sky130_fd_sc_hd__tapvpwrvgnd_1
XFILLER_45_57 VGND VGND VPWR VPWR sky130_fd_sc_hd__decap_3
XFILLER_71_446 VGND VGND VPWR VPWR sky130_fd_sc_hd__fill_2
XFILLER_52_660 VGND VGND VPWR VPWR sky130_fd_sc_hd__decap_3
XFILLER_24_395 VGND VGND VPWR VPWR sky130_fd_sc_hd__decap_3
XFILLER_51_181 VGND VGND VPWR VPWR sky130_fd_sc_hd__decap_3
XFILLER_52_693 VGND VGND VPWR VPWR sky130_fd_sc_hd__decap_3
XFILLER_61_23 VGND VGND VPWR VPWR sky130_fd_sc_hd__decap_3
XTAP_TAPCELL_ROW_61_1016 VGND VPWR sky130_fd_sc_hd__tapvpwrvgnd_1
XTAP_TAPCELL_ROW_22_530 VGND VPWR sky130_fd_sc_hd__tapvpwrvgnd_1
XTAP_TAPCELL_ROW_50_883 VGND VPWR sky130_fd_sc_hd__tapvpwrvgnd_1
XFILLER_4_701 VGND VGND VPWR VPWR sky130_fd_sc_hd__decap_3
XFILLER_106_640 VGND VGND VPWR VPWR sky130_fd_sc_hd__decap_3
XFILLER_106_651 VGND VGND VPWR VPWR sky130_fd_sc_hd__decap_3
XFILLER_3_222 VGND VGND VPWR VPWR sky130_fd_sc_hd__fill_2
XFILLER_106_684 VGND VGND VPWR VPWR sky130_fd_sc_hd__decap_3
XFILLER_3_255 VGND VGND VPWR VPWR sky130_fd_sc_hd__decap_3
XFILLER_105_172 VGND VGND VPWR VPWR sky130_fd_sc_hd__decap_3
XFILLER_10_93 VGND VGND VPWR VPWR sky130_fd_sc_hd__fill_2
XFILLER_79_557 VGND VGND VPWR VPWR sky130_fd_sc_hd__decap_3
XFILLER_79_568 VGND VGND VPWR VPWR sky130_fd_sc_hd__decap_3
XTAP_TAPCELL_ROW_72_1156 VGND VPWR sky130_fd_sc_hd__tapvpwrvgnd_1
XFILLER_66_218 VGND VGND VPWR VPWR sky130_fd_sc_hd__decap_3
XFILLER_86_64 VGND VGND VPWR VPWR sky130_fd_sc_hd__decap_3
XFILLER_86_97 VGND VGND VPWR VPWR sky130_fd_sc_hd__decap_3
XFILLER_19_167 VGND VGND VPWR VPWR sky130_fd_sc_hd__fill_1
XFILLER_19_178 VGND VGND VPWR VPWR sky130_fd_sc_hd__fill_1
XFILLER_35_638 VGND VGND VPWR VPWR sky130_fd_sc_hd__decap_3
XFILLER_62_424 VGND VGND VPWR VPWR sky130_fd_sc_hd__decap_3
XTAP_TAPCELL_ROW_58_983 VGND VPWR sky130_fd_sc_hd__tapvpwrvgnd_1
XFILLER_28_690 VGND VGND VPWR VPWR sky130_fd_sc_hd__decap_3
XFILLER_62_457 VGND VGND VPWR VPWR sky130_fd_sc_hd__decap_3
XFILLER_15_362 VGND VGND VPWR VPWR sky130_fd_sc_hd__decap_3
XFILLER_34_159 VGND VGND VPWR VPWR sky130_fd_sc_hd__decap_3
XFILLER_43_671 VGND VGND VPWR VPWR sky130_fd_sc_hd__fill_1
XFILLER_42_181 VGND VGND VPWR VPWR sky130_fd_sc_hd__decap_3
XFILLER_43_682 VGND VGND VPWR VPWR sky130_fd_sc_hd__decap_3
XTAP_TAPCELL_ROW_83_1296 VGND VPWR sky130_fd_sc_hd__tapvpwrvgnd_1
XFILLER_30_354 VGND VGND VPWR VPWR sky130_fd_sc_hd__decap_3
X_4550_ _4550_/A _4563_/B VGND VGND VPWR VPWR _7305_/D sky130_fd_sc_hd__and2_2
XFILLER_116_426 VGND VGND VPWR VPWR sky130_fd_sc_hd__decap_3
XFILLER_7_561 VGND VGND VPWR VPWR sky130_fd_sc_hd__decap_3
XFILLER_7_594 VGND VGND VPWR VPWR sky130_fd_sc_hd__decap_3
X_3501_ _5144_/A _5144_/B _3500_/Y VGND VGND VPWR VPWR _3501_/X sky130_fd_sc_hd__a21o_2
XFILLER_116_459 VGND VGND VPWR VPWR sky130_fd_sc_hd__decap_3
XFILLER_103_109 VGND VGND VPWR VPWR sky130_fd_sc_hd__decap_3
XFILLER_112_610 VGND VGND VPWR VPWR sky130_fd_sc_hd__decap_3
X_3363_ _6982_/Q _6983_/Q _6979_/Q VGND VGND VPWR VPWR _5294_/B sky130_fd_sc_hd__or3b_4
XFILLER_112_643 VGND VGND VPWR VPWR sky130_fd_sc_hd__fill_1
XFILLER_112_654 VGND VGND VPWR VPWR sky130_fd_sc_hd__decap_3
XFILLER_97_332 VGND VGND VPWR VPWR sky130_fd_sc_hd__decap_3
X_5102_ _5114_/A _4343_/X _5100_/Y _3618_/X _5101_/Y VGND VGND VPWR VPWR _5102_/X
+ sky130_fd_sc_hd__a221o_2
XFILLER_111_153 VGND VGND VPWR VPWR sky130_fd_sc_hd__decap_3
XFILLER_112_687 VGND VGND VPWR VPWR sky130_fd_sc_hd__decap_3
XFILLER_85_505 VGND VGND VPWR VPWR sky130_fd_sc_hd__decap_3
XFILLER_97_354 VGND VGND VPWR VPWR sky130_fd_sc_hd__decap_3
Xhold1206 _7250_/Q VGND VGND VPWR VPWR _5140_/A0 sky130_fd_sc_hd__dlygate4sd3_1
XFILLER_38_421 VGND VGND VPWR VPWR sky130_fd_sc_hd__fill_2
XFILLER_57_218 VGND VGND VPWR VPWR sky130_fd_sc_hd__decap_3
XFILLER_85_527 VGND VGND VPWR VPWR sky130_fd_sc_hd__decap_3
XFILLER_97_387 VGND VGND VPWR VPWR sky130_fd_sc_hd__decap_3
Xhold1217 _7300_/Q VGND VGND VPWR VPWR _4561_/A sky130_fd_sc_hd__dlygate4sd3_1
Xhold1228 _7148_/Q VGND VGND VPWR VPWR _5369_/A0 sky130_fd_sc_hd__dlygate4sd3_1
Xhold1239 _4503_/X VGND VGND VPWR VPWR _7328_/D sky130_fd_sc_hd__dlygate4sd3_1
X_5033_ _5114_/A _4629_/Y _5032_/A _5033_/B2 VGND VGND VPWR VPWR _5033_/X sky130_fd_sc_hd__a22o_2
Xsingle_cycle_cpu_680 VGND VGND VPWR VPWR instruction_out[0] single_cycle_cpu_680/LO
+ sky130_fd_sc_hd__conb_1
XFILLER_26_616 VGND VGND VPWR VPWR sky130_fd_sc_hd__decap_3
XFILLER_53_402 VGND VGND VPWR VPWR sky130_fd_sc_hd__decap_3
XFILLER_81_700 VGND VGND VPWR VPWR sky130_fd_sc_hd__decap_3
XFILLER_53_457 VGND VGND VPWR VPWR sky130_fd_sc_hd__decap_3
XFILLER_80_243 VGND VGND VPWR VPWR sky130_fd_sc_hd__decap_3
X_6984_ _7388_/CLK _6984_/D _6264_/Y VGND VGND VPWR VPWR _6984_/Q sky130_fd_sc_hd__dfrtp_2
XTAP_TAPCELL_ROW_0_258 VGND VPWR sky130_fd_sc_hd__tapvpwrvgnd_1
XTAP_TAPCELL_ROW_0_247 VGND VPWR sky130_fd_sc_hd__tapvpwrvgnd_1
XFILLER_15_27 VGND VGND VPWR VPWR sky130_fd_sc_hd__decap_3
XFILLER_34_660 VGND VGND VPWR VPWR sky130_fd_sc_hd__decap_3
XFILLER_40_107 VGND VGND VPWR VPWR sky130_fd_sc_hd__decap_3
XFILLER_80_276 VGND VGND VPWR VPWR sky130_fd_sc_hd__decap_3
XFILLER_21_310 VGND VGND VPWR VPWR sky130_fd_sc_hd__decap_3
XFILLER_33_181 VGND VGND VPWR VPWR sky130_fd_sc_hd__decap_3
XFILLER_34_693 VGND VGND VPWR VPWR sky130_fd_sc_hd__decap_3
XFILLER_21_343 VGND VGND VPWR VPWR sky130_fd_sc_hd__decap_3
X_4817_ _4810_/X _4811_/X _4815_/X _4816_/X VGND VGND VPWR VPWR _5663_/B sky130_fd_sc_hd__a211o_2
XFILLER_21_365 VGND VGND VPWR VPWR sky130_fd_sc_hd__decap_3
XFILLER_119_242 VGND VGND VPWR VPWR sky130_fd_sc_hd__fill_2
XFILLER_119_253 VGND VGND VPWR VPWR sky130_fd_sc_hd__decap_3
X_4748_ _3683_/Y _5664_/B _4791_/C1 VGND VGND VPWR VPWR _4751_/A sky130_fd_sc_hd__a21o_2
XFILLER_107_415 VGND VGND VPWR VPWR sky130_fd_sc_hd__decap_3
XFILLER_119_297 VGND VGND VPWR VPWR sky130_fd_sc_hd__fill_1
X_4679_ _6990_/Q _5014_/B VGND VGND VPWR VPWR _5015_/B sky130_fd_sc_hd__nand2_2
X_6418_ _6613_/A VGND VGND VPWR VPWR _6418_/Y sky130_fd_sc_hd__inv_2
XPHY_EDGE_ROW_1_Right_1 VGND VGND VPWR VPWR sky130_fd_sc_hd__decap_3
X_7398_ _7403_/CLK _7398_/D _6678_/Y VGND VGND VPWR VPWR _7398_/Q sky130_fd_sc_hd__dfrtp_2
XFILLER_0_225 VGND VGND VPWR VPWR sky130_fd_sc_hd__fill_1
XFILLER_103_632 VGND VGND VPWR VPWR sky130_fd_sc_hd__decap_3
XFILLER_88_332 VGND VGND VPWR VPWR sky130_fd_sc_hd__decap_3
X_6349_ _6671_/A VGND VGND VPWR VPWR _6349_/Y sky130_fd_sc_hd__inv_2
XTAP_TAPCELL_ROW_8_358 VGND VPWR sky130_fd_sc_hd__tapvpwrvgnd_1
XFILLER_103_665 VGND VGND VPWR VPWR sky130_fd_sc_hd__decap_3
XFILLER_103_676 VGND VGND VPWR VPWR sky130_fd_sc_hd__decap_3
XFILLER_48_207 VGND VGND VPWR VPWR sky130_fd_sc_hd__decap_3
XFILLER_88_365 VGND VGND VPWR VPWR sky130_fd_sc_hd__decap_3
XFILLER_102_186 VGND VGND VPWR VPWR sky130_fd_sc_hd__decap_3
XFILLER_76_549 VGND VGND VPWR VPWR sky130_fd_sc_hd__fill_1
XFILLER_88_398 VGND VGND VPWR VPWR sky130_fd_sc_hd__decap_3
XFILLER_29_432 VGND VGND VPWR VPWR sky130_fd_sc_hd__decap_3
XFILLER_91_508 VGND VGND VPWR VPWR sky130_fd_sc_hd__fill_1
XFILLER_17_605 VGND VGND VPWR VPWR sky130_fd_sc_hd__decap_3
XFILLER_17_638 VGND VGND VPWR VPWR sky130_fd_sc_hd__decap_3
XFILLER_29_465 VGND VGND VPWR VPWR sky130_fd_sc_hd__decap_3
XFILLER_29_498 VGND VGND VPWR VPWR sky130_fd_sc_hd__decap_3
XFILLER_84_582 VGND VGND VPWR VPWR sky130_fd_sc_hd__decap_3
XTAP_TAPCELL_ROW_27_600 VGND VPWR sky130_fd_sc_hd__tapvpwrvgnd_1
XFILLER_16_137 VGND VGND VPWR VPWR sky130_fd_sc_hd__decap_3
XFILLER_44_457 VGND VGND VPWR VPWR sky130_fd_sc_hd__decap_3
XTAP_TAPCELL_ROW_55_942 VGND VPWR sky130_fd_sc_hd__tapvpwrvgnd_1
XFILLER_112_62 VGND VGND VPWR VPWR sky130_fd_sc_hd__decap_3
XFILLER_25_671 VGND VGND VPWR VPWR sky130_fd_sc_hd__fill_1
XFILLER_32_619 VGND VGND VPWR VPWR sky130_fd_sc_hd__decap_3
XFILLER_44_468 VGND VGND VPWR VPWR sky130_fd_sc_hd__decap_3
XFILLER_71_254 VGND VGND VPWR VPWR sky130_fd_sc_hd__decap_3
XFILLER_25_682 VGND VGND VPWR VPWR sky130_fd_sc_hd__decap_3
XFILLER_72_77 VGND VGND VPWR VPWR sky130_fd_sc_hd__decap_3
XFILLER_12_354 VGND VGND VPWR VPWR sky130_fd_sc_hd__decap_3
XFILLER_24_192 VGND VGND VPWR VPWR sky130_fd_sc_hd__decap_3
XFILLER_40_663 VGND VGND VPWR VPWR sky130_fd_sc_hd__decap_3
XFILLER_72_99 VGND VGND VPWR VPWR sky130_fd_sc_hd__decap_3
XFILLER_12_365 VGND VGND VPWR VPWR sky130_fd_sc_hd__decap_3
XFILLER_12_387 VGND VGND VPWR VPWR sky130_fd_sc_hd__decap_3
XFILLER_40_696 VGND VGND VPWR VPWR sky130_fd_sc_hd__decap_3
XFILLER_8_336 VGND VGND VPWR VPWR sky130_fd_sc_hd__decap_3
XFILLER_8_358 VGND VGND VPWR VPWR sky130_fd_sc_hd__decap_3
XFILLER_4_542 VGND VGND VPWR VPWR sky130_fd_sc_hd__decap_3
XFILLER_113_407 VGND VGND VPWR VPWR sky130_fd_sc_hd__decap_3
XFILLER_4_575 VGND VGND VPWR VPWR sky130_fd_sc_hd__decap_3
XFILLER_98_129 VGND VGND VPWR VPWR sky130_fd_sc_hd__decap_3
XFILLER_79_332 VGND VGND VPWR VPWR sky130_fd_sc_hd__decap_3
XFILLER_79_343 VGND VGND VPWR VPWR sky130_fd_sc_hd__decap_3
XFILLER_97_63 VGND VGND VPWR VPWR sky130_fd_sc_hd__decap_3
XFILLER_39_207 VGND VGND VPWR VPWR sky130_fd_sc_hd__decap_3
XFILLER_67_505 VGND VGND VPWR VPWR sky130_fd_sc_hd__decap_3
XFILLER_94_302 VGND VGND VPWR VPWR sky130_fd_sc_hd__decap_3
XFILLER_47_240 VGND VGND VPWR VPWR sky130_fd_sc_hd__decap_3
XFILLER_94_346 VGND VGND VPWR VPWR sky130_fd_sc_hd__decap_3
XFILLER_94_368 VGND VGND VPWR VPWR sky130_fd_sc_hd__fill_1
XFILLER_63_700 VGND VGND VPWR VPWR sky130_fd_sc_hd__decap_3
XFILLER_82_519 VGND VGND VPWR VPWR sky130_fd_sc_hd__decap_3
XFILLER_35_435 VGND VGND VPWR VPWR sky130_fd_sc_hd__decap_3
XTAP_TAPCELL_ROW_85_1325 VGND VPWR sky130_fd_sc_hd__tapvpwrvgnd_1
XFILLER_16_660 VGND VGND VPWR VPWR sky130_fd_sc_hd__decap_3
XFILLER_62_243 VGND VGND VPWR VPWR sky130_fd_sc_hd__decap_3
X_3981_ _7350_/Q _4522_/A0 _3987_/S VGND VGND VPWR VPWR _3981_/X sky130_fd_sc_hd__mux2_2
XFILLER_16_693 VGND VGND VPWR VPWR sky130_fd_sc_hd__decap_3
XFILLER_22_118 VGND VGND VPWR VPWR sky130_fd_sc_hd__fill_1
XFILLER_62_287 VGND VGND VPWR VPWR sky130_fd_sc_hd__decap_3
XFILLER_90_585 VGND VGND VPWR VPWR sky130_fd_sc_hd__decap_3
XFILLER_31_641 VGND VGND VPWR VPWR sky130_fd_sc_hd__decap_3
Xclkbuf_leaf_42_clk clkbuf_leaf_1_clk/A VGND VGND VPWR VPWR clkload5/A sky130_fd_sc_hd__clkbuf_16
XTAP_TAPCELL_ROW_33_669 VGND VPWR sky130_fd_sc_hd__tapvpwrvgnd_1
XFILLER_31_685 VGND VGND VPWR VPWR sky130_fd_sc_hd__decap_3
X_5651_ _5660_/C VGND VGND VPWR VPWR _5651_/Y sky130_fd_sc_hd__inv_2
X_7321_ _7322_/CLK _7321_/D _6601_/Y VGND VGND VPWR VPWR _7321_/Q sky130_fd_sc_hd__dfrtp_2
X_7252_ _7345_/CLK _7252_/D _6532_/Y VGND VGND VPWR VPWR _7252_/Q sky130_fd_sc_hd__dfrtp_2
XTAP_TAPCELL_ROW_96_1454 VGND VPWR sky130_fd_sc_hd__tapvpwrvgnd_1
XFILLER_116_256 VGND VGND VPWR VPWR sky130_fd_sc_hd__fill_2
XFILLER_116_267 VGND VGND VPWR VPWR sky130_fd_sc_hd__decap_3
XFILLER_117_29 VGND VGND VPWR VPWR sky130_fd_sc_hd__decap_3
X_4464_ _3541_/X _3610_/B _4463_/X VGND VGND VPWR VPWR _5655_/C sky130_fd_sc_hd__o21ai_2
XFILLER_98_630 VGND VGND VPWR VPWR sky130_fd_sc_hd__decap_3
X_7183_ _7349_/CLK _7183_/D _6463_/Y VGND VGND VPWR VPWR _7183_/Q sky130_fd_sc_hd__dfrtp_2
X_4395_ _4396_/A _4444_/B VGND VGND VPWR VPWR _4397_/A sky130_fd_sc_hd__and2_2
X_3415_ _3449_/B _3449_/C _3417_/C VGND VGND VPWR VPWR _5136_/S sky130_fd_sc_hd__and3_4
XFILLER_58_505 VGND VGND VPWR VPWR sky130_fd_sc_hd__decap_3
XFILLER_58_516 VGND VGND VPWR VPWR sky130_fd_sc_hd__decap_3
XFILLER_98_663 VGND VGND VPWR VPWR sky130_fd_sc_hd__decap_3
X_3346_ _3346_/A VGND VGND VPWR VPWR _3509_/B sky130_fd_sc_hd__inv_2
XTAP_TAPCELL_ROW_5_317 VGND VPWR sky130_fd_sc_hd__tapvpwrvgnd_1
XFILLER_100_635 VGND VGND VPWR VPWR sky130_fd_sc_hd__decap_3
XFILLER_112_484 VGND VGND VPWR VPWR sky130_fd_sc_hd__decap_3
XFILLER_85_302 VGND VGND VPWR VPWR sky130_fd_sc_hd__decap_3
XFILLER_97_162 VGND VGND VPWR VPWR sky130_fd_sc_hd__decap_3
XFILLER_97_195 VGND VGND VPWR VPWR sky130_fd_sc_hd__decap_3
XFILLER_98_696 VGND VGND VPWR VPWR sky130_fd_sc_hd__decap_3
Xhold1003 _7110_/Q VGND VGND VPWR VPWR _7110_/D sky130_fd_sc_hd__dlygate4sd3_1
Xhold1014 _6707_/Q VGND VGND VPWR VPWR _5715_/A1 sky130_fd_sc_hd__dlygate4sd3_1
XFILLER_100_657 VGND VGND VPWR VPWR sky130_fd_sc_hd__decap_3
XFILLER_73_508 VGND VGND VPWR VPWR sky130_fd_sc_hd__decap_3
XFILLER_85_357 VGND VGND VPWR VPWR sky130_fd_sc_hd__fill_1
Xhold1025 _7387_/Q VGND VGND VPWR VPWR _3857_/A1 sky130_fd_sc_hd__dlygate4sd3_1
Xhold1036 _6718_/Q VGND VGND VPWR VPWR _5737_/A1 sky130_fd_sc_hd__dlygate4sd3_1
Xhold1047 _7315_/Q VGND VGND VPWR VPWR _4528_/A sky130_fd_sc_hd__dlygate4sd3_1
Xhold1058 _7034_/Q VGND VGND VPWR VPWR _5587_/A sky130_fd_sc_hd__dlygate4sd3_1
X_5016_ _5032_/A _5031_/B _4629_/Y VGND VGND VPWR VPWR _5017_/B sky130_fd_sc_hd__a21oi_2
XFILLER_85_379 VGND VGND VPWR VPWR sky130_fd_sc_hd__decap_3
Xhold1069 _7018_/Q VGND VGND VPWR VPWR _5619_/A sky130_fd_sc_hd__dlygate4sd3_1
XFILLER_26_446 VGND VGND VPWR VPWR sky130_fd_sc_hd__decap_3
XFILLER_14_619 VGND VGND VPWR VPWR sky130_fd_sc_hd__decap_3
XFILLER_26_59 VGND VGND VPWR VPWR sky130_fd_sc_hd__fill_2
XFILLER_53_243 VGND VGND VPWR VPWR sky130_fd_sc_hd__decap_3
XFILLER_81_552 VGND VGND VPWR VPWR sky130_fd_sc_hd__decap_3
XFILLER_81_574 VGND VGND VPWR VPWR sky130_fd_sc_hd__fill_1
X_6967_ clkload5/A _6967_/D VGND VGND VPWR VPWR _6967_/Q sky130_fd_sc_hd__dfxtp_2
XTAP_TAPCELL_ROW_52_912 VGND VPWR sky130_fd_sc_hd__tapvpwrvgnd_1
XFILLER_41_449 VGND VGND VPWR VPWR sky130_fd_sc_hd__decap_3
XFILLER_53_287 VGND VGND VPWR VPWR sky130_fd_sc_hd__decap_3
XFILLER_81_596 VGND VGND VPWR VPWR sky130_fd_sc_hd__decap_3
XTAP_TAPCELL_ROW_105_1572 VGND VPWR sky130_fd_sc_hd__tapvpwrvgnd_1
Xclkbuf_leaf_33_clk clkbuf_3_2__f_clk/X VGND VGND VPWR VPWR _7350_/CLK sky130_fd_sc_hd__clkbuf_16
X_6898_ _6906_/CLK _6898_/D VGND VGND VPWR VPWR _6898_/Q sky130_fd_sc_hd__dfxtp_2
XFILLER_21_162 VGND VGND VPWR VPWR sky130_fd_sc_hd__decap_3
XFILLER_22_663 VGND VGND VPWR VPWR sky130_fd_sc_hd__decap_3
XFILLER_22_696 VGND VGND VPWR VPWR sky130_fd_sc_hd__decap_3
XFILLER_108_713 VGND VGND VPWR VPWR sky130_fd_sc_hd__fill_1
XFILLER_5_317 VGND VGND VPWR VPWR sky130_fd_sc_hd__decap_3
XFILLER_1_523 VGND VGND VPWR VPWR sky130_fd_sc_hd__decap_3
XFILLER_89_641 VGND VGND VPWR VPWR sky130_fd_sc_hd__decap_3
Xhold870 _6834_/Q VGND VGND VPWR VPWR _6834_/D sky130_fd_sc_hd__dlygate4sd3_1
Xhold881 _6850_/Q VGND VGND VPWR VPWR _6850_/D sky130_fd_sc_hd__dlygate4sd3_1
XFILLER_107_84 VGND VGND VPWR VPWR sky130_fd_sc_hd__decap_3
XFILLER_1_556 VGND VGND VPWR VPWR sky130_fd_sc_hd__decap_3
XFILLER_1_567 VGND VGND VPWR VPWR sky130_fd_sc_hd__decap_3
XFILLER_49_505 VGND VGND VPWR VPWR sky130_fd_sc_hd__decap_3
Xhold892 _6917_/Q VGND VGND VPWR VPWR _6917_/D sky130_fd_sc_hd__dlygate4sd3_1
XFILLER_67_44 VGND VGND VPWR VPWR sky130_fd_sc_hd__decap_3
XFILLER_88_162 VGND VGND VPWR VPWR sky130_fd_sc_hd__decap_3
XFILLER_89_685 VGND VGND VPWR VPWR sky130_fd_sc_hd__decap_3
XFILLER_76_335 VGND VGND VPWR VPWR sky130_fd_sc_hd__decap_3
XFILLER_76_357 VGND VGND VPWR VPWR sky130_fd_sc_hd__decap_3
XFILLER_76_368 VGND VGND VPWR VPWR sky130_fd_sc_hd__fill_2
XFILLER_88_195 VGND VGND VPWR VPWR sky130_fd_sc_hd__fill_1
XFILLER_17_402 VGND VGND VPWR VPWR sky130_fd_sc_hd__decap_3
XFILLER_29_240 VGND VGND VPWR VPWR sky130_fd_sc_hd__decap_3
XFILLER_29_273 VGND VGND VPWR VPWR sky130_fd_sc_hd__decap_3
XFILLER_45_700 VGND VGND VPWR VPWR sky130_fd_sc_hd__decap_3
XFILLER_57_582 VGND VGND VPWR VPWR sky130_fd_sc_hd__fill_1
XFILLER_64_519 VGND VGND VPWR VPWR sky130_fd_sc_hd__decap_3
XFILLER_91_327 VGND VGND VPWR VPWR sky130_fd_sc_hd__decap_3
XFILLER_17_424 VGND VGND VPWR VPWR sky130_fd_sc_hd__decap_3
XFILLER_29_284 VGND VGND VPWR VPWR sky130_fd_sc_hd__decap_3
XFILLER_44_221 VGND VGND VPWR VPWR sky130_fd_sc_hd__decap_3
XFILLER_72_530 VGND VGND VPWR VPWR sky130_fd_sc_hd__fill_2
XFILLER_84_390 VGND VGND VPWR VPWR sky130_fd_sc_hd__decap_3
XFILLER_17_468 VGND VGND VPWR VPWR sky130_fd_sc_hd__decap_3
XFILLER_44_243 VGND VGND VPWR VPWR sky130_fd_sc_hd__decap_3
XFILLER_83_87 VGND VGND VPWR VPWR sky130_fd_sc_hd__decap_3
XFILLER_32_427 VGND VGND VPWR VPWR sky130_fd_sc_hd__fill_2
XTAP_TAPCELL_ROW_67_1099 VGND VPWR sky130_fd_sc_hd__tapvpwrvgnd_1
XFILLER_13_641 VGND VGND VPWR VPWR sky130_fd_sc_hd__decap_3
XFILLER_25_490 VGND VGND VPWR VPWR sky130_fd_sc_hd__decap_3
Xclkbuf_leaf_24_clk clkbuf_3_6__f_clk/X VGND VGND VPWR VPWR _7333_/CLK sky130_fd_sc_hd__clkbuf_16
XFILLER_12_151 VGND VGND VPWR VPWR sky130_fd_sc_hd__decap_3
XFILLER_13_685 VGND VGND VPWR VPWR sky130_fd_sc_hd__decap_3
XFILLER_80_9 VGND VGND VPWR VPWR sky130_fd_sc_hd__decap_3
XTAP_TAPCELL_ROW_80_1255 VGND VPWR sky130_fd_sc_hd__tapvpwrvgnd_1
XTAP_TAPCELL_ROW_30_628 VGND VPWR sky130_fd_sc_hd__tapvpwrvgnd_1
XFILLER_9_623 VGND VGND VPWR VPWR sky130_fd_sc_hd__decap_3
XFILLER_9_612 VGND VGND VPWR VPWR sky130_fd_sc_hd__decap_3
XFILLER_8_144 VGND VGND VPWR VPWR sky130_fd_sc_hd__decap_3
XTAP_TAPCELL_ROW_30_639 VGND VPWR sky130_fd_sc_hd__tapvpwrvgnd_1
XFILLER_9_656 VGND VGND VPWR VPWR sky130_fd_sc_hd__decap_3
XTAP_TAPCELL_ROW_10_385 VGND VPWR sky130_fd_sc_hd__tapvpwrvgnd_1
XFILLER_99_427 VGND VGND VPWR VPWR sky130_fd_sc_hd__decap_3
XFILLER_99_449 VGND VGND VPWR VPWR sky130_fd_sc_hd__decap_3
XFILLER_79_140 VGND VGND VPWR VPWR sky130_fd_sc_hd__decap_3
X_4180_ _7232_/Q _3318_/B _4300_/B _7045_/Q VGND VGND VPWR VPWR _4180_/X sky130_fd_sc_hd__a22o_2
XFILLER_79_162 VGND VGND VPWR VPWR sky130_fd_sc_hd__decap_3
XFILLER_79_184 VGND VGND VPWR VPWR sky130_fd_sc_hd__decap_3
XTAP_TAPCELL_ROW_91_1395 VGND VPWR sky130_fd_sc_hd__tapvpwrvgnd_1
XFILLER_67_335 VGND VGND VPWR VPWR sky130_fd_sc_hd__fill_1
XFILLER_67_357 VGND VGND VPWR VPWR sky130_fd_sc_hd__decap_3
XFILLER_95_644 VGND VGND VPWR VPWR sky130_fd_sc_hd__decap_3
XFILLER_82_316 VGND VGND VPWR VPWR sky130_fd_sc_hd__fill_2
XFILLER_95_688 VGND VGND VPWR VPWR sky130_fd_sc_hd__decap_3
XTAP_TAPCELL_ROW_38_728 VGND VPWR sky130_fd_sc_hd__tapvpwrvgnd_1
XFILLER_48_582 VGND VGND VPWR VPWR sky130_fd_sc_hd__fill_1
XFILLER_94_187 VGND VGND VPWR VPWR sky130_fd_sc_hd__decap_3
XTAP_TAPCELL_ROW_38_739 VGND VPWR sky130_fd_sc_hd__tapvpwrvgnd_1
XFILLER_23_405 VGND VGND VPWR VPWR sky130_fd_sc_hd__decap_3
XFILLER_51_703 VGND VGND VPWR VPWR sky130_fd_sc_hd__decap_3
Xplace530 _6654_/A VGND VGND VPWR VPWR _6686_/A sky130_fd_sc_hd__buf_2
X_6821_ clkload3/A _6821_/D VGND VGND VPWR VPWR _6821_/Q sky130_fd_sc_hd__dfxtp_2
XFILLER_50_224 VGND VGND VPWR VPWR sky130_fd_sc_hd__decap_3
XFILLER_90_360 VGND VGND VPWR VPWR sky130_fd_sc_hd__decap_3
XFILLER_90_371 VGND VGND VPWR VPWR sky130_fd_sc_hd__decap_3
Xplace541 _6642_/A VGND VGND VPWR VPWR _6667_/A sky130_fd_sc_hd__buf_2
Xplace552 _6570_/A VGND VGND VPWR VPWR _6571_/A sky130_fd_sc_hd__buf_2
Xplace563 _6626_/A VGND VGND VPWR VPWR _6635_/A sky130_fd_sc_hd__buf_2
XTAP_TAPCELL_ROW_18_485 VGND VPWR sky130_fd_sc_hd__tapvpwrvgnd_1
Xclkbuf_leaf_15_clk clkbuf_leaf_9_clk/A VGND VGND VPWR VPWR _7403_/CLK sky130_fd_sc_hd__clkbuf_16
X_6752_ _7189_/CLK _6752_/D VGND VGND VPWR VPWR _6752_/Q sky130_fd_sc_hd__dfxtp_2
X_3964_ _3964_/A0 _7326_/Q _3964_/S VGND VGND VPWR VPWR _7358_/D sky130_fd_sc_hd__mux2_2
XFILLER_50_268 VGND VGND VPWR VPWR sky130_fd_sc_hd__fill_2
X_6683_ _6683_/A VGND VGND VPWR VPWR _6683_/Y sky130_fd_sc_hd__inv_2
X_5703_ _7357_/Q _5703_/A1 _5721_/S VGND VGND VPWR VPWR _6701_/D sky130_fd_sc_hd__mux2_2
X_3895_ _3629_/A _3887_/X _3889_/X _3741_/X _3894_/X VGND VGND VPWR VPWR _3895_/X
+ sky130_fd_sc_hd__a221o_2
XFILLER_31_482 VGND VGND VPWR VPWR sky130_fd_sc_hd__decap_3
X_5634_ _5634_/A _5634_/B VGND VGND VPWR VPWR _7011_/D sky130_fd_sc_hd__and2_2
X_7304_ _7342_/CLK _7304_/D _6584_/Y VGND VGND VPWR VPWR _7304_/Q sky130_fd_sc_hd__dfrtp_2
XFILLER_2_309 VGND VGND VPWR VPWR sky130_fd_sc_hd__decap_3
X_7235_ _7370_/CLK _7235_/D _6515_/Y VGND VGND VPWR VPWR _7235_/Q sky130_fd_sc_hd__dfrtp_2
X_4447_ _4447_/A _4447_/B VGND VGND VPWR VPWR _4447_/Y sky130_fd_sc_hd__nor2_2
XFILLER_104_248 VGND VGND VPWR VPWR sky130_fd_sc_hd__decap_3
XFILLER_104_259 VGND VGND VPWR VPWR sky130_fd_sc_hd__decap_3
X_7166_ _7358_/CLK _7166_/D _6446_/Y VGND VGND VPWR VPWR _7166_/Q sky130_fd_sc_hd__dfrtp_2
X_4378_ _4243_/Y _4277_/Y _5032_/B _4377_/Y VGND VGND VPWR VPWR _4968_/A sky130_fd_sc_hd__a31o_4
XFILLER_100_421 VGND VGND VPWR VPWR sky130_fd_sc_hd__decap_3
XFILLER_100_443 VGND VGND VPWR VPWR sky130_fd_sc_hd__decap_3
XFILLER_85_143 VGND VGND VPWR VPWR sky130_fd_sc_hd__decap_3
XFILLER_86_666 VGND VGND VPWR VPWR sky130_fd_sc_hd__decap_3
X_7097_ _7322_/CLK _7097_/D _6377_/Y VGND VGND VPWR VPWR _7097_/Q sky130_fd_sc_hd__dfrtp_2
X_3329_ _3340_/A _3340_/C VGND VGND VPWR VPWR _3329_/Y sky130_fd_sc_hd__nand2_2
XFILLER_27_700 VGND VGND VPWR VPWR sky130_fd_sc_hd__decap_3
XFILLER_58_368 VGND VGND VPWR VPWR sky130_fd_sc_hd__decap_3
XFILLER_86_699 VGND VGND VPWR VPWR sky130_fd_sc_hd__fill_1
XTAP_TAPCELL_ROW_107_1601 VGND VPWR sky130_fd_sc_hd__tapvpwrvgnd_1
XFILLER_26_221 VGND VGND VPWR VPWR sky130_fd_sc_hd__decap_3
XFILLER_37_69 VGND VGND VPWR VPWR sky130_fd_sc_hd__decap_3
XFILLER_85_198 VGND VGND VPWR VPWR sky130_fd_sc_hd__decap_3
XFILLER_54_541 VGND VGND VPWR VPWR sky130_fd_sc_hd__fill_1
XFILLER_14_427 VGND VGND VPWR VPWR sky130_fd_sc_hd__decap_3
XFILLER_26_287 VGND VGND VPWR VPWR sky130_fd_sc_hd__decap_3
XFILLER_81_371 VGND VGND VPWR VPWR sky130_fd_sc_hd__decap_3
XFILLER_53_46 VGND VGND VPWR VPWR sky130_fd_sc_hd__fill_2
XFILLER_53_57 VGND VGND VPWR VPWR sky130_fd_sc_hd__fill_2
XFILLER_81_393 VGND VGND VPWR VPWR sky130_fd_sc_hd__decap_3
XFILLER_10_622 VGND VGND VPWR VPWR sky130_fd_sc_hd__decap_3
XFILLER_10_666 VGND VGND VPWR VPWR sky130_fd_sc_hd__decap_3
XFILLER_6_604 VGND VGND VPWR VPWR sky130_fd_sc_hd__decap_3
XTAP_TAPCELL_ROW_118_1730 VGND VPWR sky130_fd_sc_hd__tapvpwrvgnd_1
XFILLER_10_699 VGND VGND VPWR VPWR sky130_fd_sc_hd__fill_1
XFILLER_6_637 VGND VGND VPWR VPWR sky130_fd_sc_hd__decap_3
XFILLER_6_648 VGND VGND VPWR VPWR sky130_fd_sc_hd__decap_3
XFILLER_108_587 VGND VGND VPWR VPWR sky130_fd_sc_hd__fill_1
XFILLER_118_50 VGND VGND VPWR VPWR sky130_fd_sc_hd__decap_3
XFILLER_5_169 VGND VGND VPWR VPWR sky130_fd_sc_hd__decap_3
XFILLER_108_598 VGND VGND VPWR VPWR sky130_fd_sc_hd__decap_3
XFILLER_118_83 VGND VGND VPWR VPWR sky130_fd_sc_hd__fill_1
XFILLER_78_32 VGND VGND VPWR VPWR sky130_fd_sc_hd__fill_2
XFILLER_118_94 VGND VGND VPWR VPWR sky130_fd_sc_hd__decap_3
XFILLER_78_65 VGND VGND VPWR VPWR sky130_fd_sc_hd__decap_3
XFILLER_103_270 VGND VGND VPWR VPWR sky130_fd_sc_hd__decap_3
XFILLER_77_644 VGND VGND VPWR VPWR sky130_fd_sc_hd__decap_3
XFILLER_37_508 VGND VGND VPWR VPWR sky130_fd_sc_hd__decap_3
XFILLER_49_379 VGND VGND VPWR VPWR sky130_fd_sc_hd__fill_2
XFILLER_77_688 VGND VGND VPWR VPWR sky130_fd_sc_hd__decap_3
XFILLER_92_625 VGND VGND VPWR VPWR sky130_fd_sc_hd__decap_3
XTAP_TAPCELL_ROW_69_1117 VGND VPWR sky130_fd_sc_hd__tapvpwrvgnd_1
XFILLER_45_530 VGND VGND VPWR VPWR sky130_fd_sc_hd__decap_3
XFILLER_91_113 VGND VGND VPWR VPWR sky130_fd_sc_hd__fill_2
XFILLER_91_124 VGND VGND VPWR VPWR sky130_fd_sc_hd__decap_3
XFILLER_94_75 VGND VGND VPWR VPWR sky130_fd_sc_hd__decap_3
XFILLER_17_243 VGND VGND VPWR VPWR sky130_fd_sc_hd__fill_1
XFILLER_33_703 VGND VGND VPWR VPWR sky130_fd_sc_hd__decap_3
XFILLER_91_157 VGND VGND VPWR VPWR sky130_fd_sc_hd__decap_3
XFILLER_92_669 VGND VGND VPWR VPWR sky130_fd_sc_hd__decap_3
XFILLER_94_97 VGND VGND VPWR VPWR sky130_fd_sc_hd__decap_3
XFILLER_17_265 VGND VGND VPWR VPWR sky130_fd_sc_hd__decap_3
XFILLER_17_276 VGND VGND VPWR VPWR sky130_fd_sc_hd__decap_3
XFILLER_27_91 VGND VGND VPWR VPWR sky130_fd_sc_hd__decap_3
XFILLER_45_596 VGND VGND VPWR VPWR sky130_fd_sc_hd__decap_3
XFILLER_72_371 VGND VGND VPWR VPWR sky130_fd_sc_hd__decap_3
XFILLER_32_246 VGND VGND VPWR VPWR sky130_fd_sc_hd__decap_3
XFILLER_60_533 VGND VGND VPWR VPWR sky130_fd_sc_hd__decap_3
XTAP_TAPCELL_ROW_15_444 VGND VPWR sky130_fd_sc_hd__tapvpwrvgnd_1
XFILLER_13_493 VGND VGND VPWR VPWR sky130_fd_sc_hd__fill_2
XTAP_TAPCELL_ROW_43_797 VGND VPWR sky130_fd_sc_hd__tapvpwrvgnd_1
XFILLER_9_420 VGND VGND VPWR VPWR sky130_fd_sc_hd__decap_3
X_3680_ _3677_/Y _3912_/A2 _3925_/B1 _3679_/Y VGND VGND VPWR VPWR _3680_/X sky130_fd_sc_hd__a22o_2
XFILLER_9_464 VGND VGND VPWR VPWR sky130_fd_sc_hd__fill_1
X_5350_ _5350_/A0 _5131_/X _5360_/S VGND VGND VPWR VPWR _7156_/D sky130_fd_sc_hd__mux2_2
XTAP_TAPCELL_ROW_93_1424 VGND VPWR sky130_fd_sc_hd__tapvpwrvgnd_1
XFILLER_114_524 VGND VGND VPWR VPWR sky130_fd_sc_hd__decap_3
X_4301_ _7352_/Q _4346_/B1 _4339_/B1 _7160_/Q _4300_/X VGND VGND VPWR VPWR _4301_/X
+ sky130_fd_sc_hd__a221o_2
XFILLER_114_579 VGND VGND VPWR VPWR sky130_fd_sc_hd__decap_3
XFILLER_87_419 VGND VGND VPWR VPWR sky130_fd_sc_hd__decap_3
X_7020_ _7342_/CLK _7020_/D _6300_/Y VGND VGND VPWR VPWR _7020_/Q sky130_fd_sc_hd__dfrtp_2
X_4232_ _4228_/X _4231_/X _4327_/A VGND VGND VPWR VPWR _4628_/A sky130_fd_sc_hd__o21a_2
XFILLER_99_257 VGND VGND VPWR VPWR sky130_fd_sc_hd__decap_3
XFILLER_101_218 VGND VGND VPWR VPWR sky130_fd_sc_hd__decap_3
XFILLER_4_73 VGND VGND VPWR VPWR sky130_fd_sc_hd__decap_3
XFILLER_68_600 VGND VGND VPWR VPWR sky130_fd_sc_hd__decap_3
Xclkbuf_leaf_4_clk clkbuf_leaf_6_clk/A VGND VGND VPWR VPWR clkload9/A sky130_fd_sc_hd__clkbuf_16
XFILLER_99_279 VGND VGND VPWR VPWR sky130_fd_sc_hd__fill_1
XFILLER_67_121 VGND VGND VPWR VPWR sky130_fd_sc_hd__decap_3
XFILLER_68_633 VGND VGND VPWR VPWR sky130_fd_sc_hd__decap_3
XFILLER_68_666 VGND VGND VPWR VPWR sky130_fd_sc_hd__decap_3
X_4163_ _7073_/Q _4265_/B _4205_/A VGND VGND VPWR VPWR _4203_/B sky130_fd_sc_hd__o21a_2
XFILLER_28_508 VGND VGND VPWR VPWR sky130_fd_sc_hd__decap_3
XFILLER_67_176 VGND VGND VPWR VPWR sky130_fd_sc_hd__decap_3
XFILLER_68_699 VGND VGND VPWR VPWR sky130_fd_sc_hd__fill_1
XFILLER_83_614 VGND VGND VPWR VPWR sky130_fd_sc_hd__fill_2
XFILLER_95_452 VGND VGND VPWR VPWR sky130_fd_sc_hd__fill_2
XFILLER_95_463 VGND VGND VPWR VPWR sky130_fd_sc_hd__decap_3
X_4094_ _4095_/A _4210_/B VGND VGND VPWR VPWR _4096_/A sky130_fd_sc_hd__or2_2
XFILLER_55_349 VGND VGND VPWR VPWR sky130_fd_sc_hd__decap_3
XFILLER_67_198 VGND VGND VPWR VPWR sky130_fd_sc_hd__decap_3
XFILLER_82_124 VGND VGND VPWR VPWR sky130_fd_sc_hd__decap_3
XFILLER_83_647 VGND VGND VPWR VPWR sky130_fd_sc_hd__decap_3
XFILLER_51_511 VGND VGND VPWR VPWR sky130_fd_sc_hd__decap_3
XFILLER_91_691 VGND VGND VPWR VPWR sky130_fd_sc_hd__decap_3
XFILLER_90_190 VGND VGND VPWR VPWR sky130_fd_sc_hd__fill_2
Xplace382 _5737_/S VGND VGND VPWR VPWR _5721_/S sky130_fd_sc_hd__buf_2
Xplace371 _5292_/S VGND VGND VPWR VPWR _5272_/S sky130_fd_sc_hd__buf_2
Xplace360 _4765_/A VGND VGND VPWR VPWR _4788_/A sky130_fd_sc_hd__buf_2
X_6804_ _6941_/CLK _6804_/D VGND VGND VPWR VPWR _6804_/Q sky130_fd_sc_hd__dfxtp_2
X_4996_ _4799_/A _5657_/D _3817_/X _3346_/A VGND VGND VPWR VPWR _4996_/X sky130_fd_sc_hd__o211a_2
XTAP_TAPCELL_ROW_102_1531 VGND VPWR sky130_fd_sc_hd__tapvpwrvgnd_1
Xplace393 _5390_/S VGND VGND VPWR VPWR _5379_/S sky130_fd_sc_hd__buf_2
X_6735_ _6906_/CLK _6735_/D VGND VGND VPWR VPWR _6735_/Q sky130_fd_sc_hd__dfxtp_2
X_3947_ _7366_/Q _7334_/Q _3947_/S VGND VGND VPWR VPWR _7366_/D sky130_fd_sc_hd__mux2_2
XFILLER_109_318 VGND VGND VPWR VPWR sky130_fd_sc_hd__decap_3
X_6666_ _6671_/A VGND VGND VPWR VPWR _6666_/Y sky130_fd_sc_hd__inv_2
X_3878_ _6729_/Q _3893_/B1 _3883_/B1 _6741_/Q VGND VGND VPWR VPWR _3878_/X sky130_fd_sc_hd__a22o_2
X_6597_ _6630_/A VGND VGND VPWR VPWR _6597_/Y sky130_fd_sc_hd__inv_2
X_5617_ _5617_/A _5634_/B VGND VGND VPWR VPWR _7019_/D sky130_fd_sc_hd__and2_2
XFILLER_3_607 VGND VGND VPWR VPWR sky130_fd_sc_hd__decap_3
XFILLER_105_524 VGND VGND VPWR VPWR sky130_fd_sc_hd__fill_1
XFILLER_3_629 VGND VGND VPWR VPWR sky130_fd_sc_hd__decap_3
XFILLER_2_139 VGND VGND VPWR VPWR sky130_fd_sc_hd__fill_1
XFILLER_78_408 VGND VGND VPWR VPWR sky130_fd_sc_hd__decap_3
X_7218_ _7355_/CLK _7218_/D _6498_/Y VGND VGND VPWR VPWR _7218_/Q sky130_fd_sc_hd__dfrtp_2
XFILLER_59_611 VGND VGND VPWR VPWR sky130_fd_sc_hd__decap_3
XTAP_TAPCELL_ROW_113_1671 VGND VPWR sky130_fd_sc_hd__tapvpwrvgnd_1
XFILLER_59_644 VGND VGND VPWR VPWR sky130_fd_sc_hd__decap_3
XFILLER_86_430 VGND VGND VPWR VPWR sky130_fd_sc_hd__decap_3
X_7149_ _7372_/CLK _7149_/D _6429_/Y VGND VGND VPWR VPWR _7149_/Q sky130_fd_sc_hd__dfrtp_2
XFILLER_100_251 VGND VGND VPWR VPWR sky130_fd_sc_hd__fill_1
XFILLER_100_262 VGND VGND VPWR VPWR sky130_fd_sc_hd__decap_3
XFILLER_46_305 VGND VGND VPWR VPWR sky130_fd_sc_hd__decap_3
XFILLER_58_165 VGND VGND VPWR VPWR sky130_fd_sc_hd__decap_3
XFILLER_59_688 VGND VGND VPWR VPWR sky130_fd_sc_hd__decap_3
XFILLER_86_463 VGND VGND VPWR VPWR sky130_fd_sc_hd__decap_3
XFILLER_100_284 VGND VGND VPWR VPWR sky130_fd_sc_hd__decap_3
XFILLER_104_41 VGND VGND VPWR VPWR sky130_fd_sc_hd__decap_3
XFILLER_46_338 VGND VGND VPWR VPWR sky130_fd_sc_hd__fill_2
XFILLER_58_187 VGND VGND VPWR VPWR sky130_fd_sc_hd__fill_1
XFILLER_73_113 VGND VGND VPWR VPWR sky130_fd_sc_hd__decap_3
XFILLER_74_636 VGND VGND VPWR VPWR sky130_fd_sc_hd__decap_3
XFILLER_104_85 VGND VGND VPWR VPWR sky130_fd_sc_hd__decap_3
XFILLER_15_703 VGND VGND VPWR VPWR sky130_fd_sc_hd__decap_3
XFILLER_74_669 VGND VGND VPWR VPWR sky130_fd_sc_hd__decap_3
XFILLER_27_585 VGND VGND VPWR VPWR sky130_fd_sc_hd__decap_3
XFILLER_42_511 VGND VGND VPWR VPWR sky130_fd_sc_hd__fill_2
XFILLER_54_360 VGND VGND VPWR VPWR sky130_fd_sc_hd__decap_3
XFILLER_42_533 VGND VGND VPWR VPWR sky130_fd_sc_hd__fill_2
XFILLER_54_393 VGND VGND VPWR VPWR sky130_fd_sc_hd__decap_3
XFILLER_14_268 VGND VGND VPWR VPWR sky130_fd_sc_hd__decap_3
XTAP_TAPCELL_ROW_64_1058 VGND VPWR sky130_fd_sc_hd__tapvpwrvgnd_1
XTAP_TAPCELL_ROW_12_414 VGND VPWR sky130_fd_sc_hd__tapvpwrvgnd_1
XTAP_TAPCELL_ROW_12_403 VGND VPWR sky130_fd_sc_hd__tapvpwrvgnd_1
XFILLER_80_88 VGND VGND VPWR VPWR sky130_fd_sc_hd__decap_3
XTAP_TAPCELL_ROW_40_756 VGND VPWR sky130_fd_sc_hd__tapvpwrvgnd_1
XFILLER_108_362 VGND VGND VPWR VPWR sky130_fd_sc_hd__fill_2
XFILLER_2_640 VGND VGND VPWR VPWR sky130_fd_sc_hd__decap_3
XFILLER_2_651 VGND VGND VPWR VPWR sky130_fd_sc_hd__decap_3
XFILLER_89_97 VGND VGND VPWR VPWR sky130_fd_sc_hd__decap_3
XFILLER_97_706 VGND VGND VPWR VPWR sky130_fd_sc_hd__decap_3
XFILLER_111_505 VGND VGND VPWR VPWR sky130_fd_sc_hd__decap_3
XFILLER_2_684 VGND VGND VPWR VPWR sky130_fd_sc_hd__decap_3
XTAP_TAPCELL_ROW_75_1198 VGND VPWR sky130_fd_sc_hd__tapvpwrvgnd_1
XFILLER_49_165 VGND VGND VPWR VPWR sky130_fd_sc_hd__decap_3
XFILLER_77_452 VGND VGND VPWR VPWR sky130_fd_sc_hd__decap_3
XFILLER_92_400 VGND VGND VPWR VPWR sky130_fd_sc_hd__decap_3
XFILLER_37_316 VGND VGND VPWR VPWR sky130_fd_sc_hd__decap_3
XFILLER_37_349 VGND VGND VPWR VPWR sky130_fd_sc_hd__decap_3
XFILLER_49_198 VGND VGND VPWR VPWR sky130_fd_sc_hd__decap_3
XFILLER_64_113 VGND VGND VPWR VPWR sky130_fd_sc_hd__decap_3
XFILLER_65_647 VGND VGND VPWR VPWR sky130_fd_sc_hd__decap_3
XFILLER_77_485 VGND VGND VPWR VPWR sky130_fd_sc_hd__decap_3
XFILLER_18_552 VGND VGND VPWR VPWR sky130_fd_sc_hd__fill_1
XFILLER_64_135 VGND VGND VPWR VPWR sky130_fd_sc_hd__decap_3
XFILLER_64_168 VGND VGND VPWR VPWR sky130_fd_sc_hd__decap_3
XFILLER_80_606 VGND VGND VPWR VPWR sky130_fd_sc_hd__decap_3
XFILLER_92_444 VGND VGND VPWR VPWR sky130_fd_sc_hd__decap_3
XFILLER_92_477 VGND VGND VPWR VPWR sky130_fd_sc_hd__decap_3
Xclkbuf_3_7__f_clk clkbuf_0_clk/X VGND VGND VPWR VPWR clkload2/A sky130_fd_sc_hd__clkbuf_16
XTAP_TAPCELL_ROW_48_856 VGND VPWR sky130_fd_sc_hd__tapvpwrvgnd_1
XFILLER_18_574 VGND VGND VPWR VPWR sky130_fd_sc_hd__decap_3
XFILLER_33_511 VGND VGND VPWR VPWR sky130_fd_sc_hd__fill_1
XFILLER_80_639 VGND VGND VPWR VPWR sky130_fd_sc_hd__decap_3
XFILLER_73_691 VGND VGND VPWR VPWR sky130_fd_sc_hd__decap_3
X_4850_ _4142_/X _4849_/Y _4633_/A VGND VGND VPWR VPWR _4850_/Y sky130_fd_sc_hd__o21ai_2
XFILLER_20_205 VGND VGND VPWR VPWR sky130_fd_sc_hd__fill_1
XFILLER_21_706 VGND VGND VPWR VPWR sky130_fd_sc_hd__decap_3
XFILLER_33_588 VGND VGND VPWR VPWR sky130_fd_sc_hd__decap_3
XFILLER_60_363 VGND VGND VPWR VPWR sky130_fd_sc_hd__fill_1
XFILLER_60_374 VGND VGND VPWR VPWR sky130_fd_sc_hd__decap_3
X_3801_ _3735_/X _3798_/X _3800_/X _3714_/X VGND VGND VPWR VPWR _3801_/X sky130_fd_sc_hd__a22o_2
X_6520_ _6648_/A VGND VGND VPWR VPWR _6520_/Y sky130_fd_sc_hd__inv_2
X_4781_ _4444_/X _4780_/Y _4413_/A VGND VGND VPWR VPWR _4781_/X sky130_fd_sc_hd__o21a_2
X_3732_ _6776_/Q _3912_/A2 _3913_/A2 _6764_/Q _3731_/X VGND VGND VPWR VPWR _3732_/X
+ sky130_fd_sc_hd__a221o_2
XFILLER_9_261 VGND VGND VPWR VPWR sky130_fd_sc_hd__decap_3
XFILLER_9_250 VGND VGND VPWR VPWR sky130_fd_sc_hd__fill_2
Xclkload20 _7322_/CLK VGND VGND VPWR VPWR clkload20/Y sky130_fd_sc_hd__bufinv_16
X_6451_ _6550_/A VGND VGND VPWR VPWR _6451_/Y sky130_fd_sc_hd__inv_2
Xclkload31 _7360_/CLK VGND VGND VPWR VPWR clkload31/X sky130_fd_sc_hd__clkbuf_1
X_6382_ _6608_/A VGND VGND VPWR VPWR _6382_/Y sky130_fd_sc_hd__inv_2
X_5402_ _5402_/A0 _5027_/X _5402_/S VGND VGND VPWR VPWR _7132_/D sky130_fd_sc_hd__mux2_2
X_5333_ _5333_/A0 _5027_/X _5340_/S VGND VGND VPWR VPWR _7164_/D sky130_fd_sc_hd__mux2_2
X_3594_ _4292_/A _3594_/B VGND VGND VPWR VPWR _3594_/Y sky130_fd_sc_hd__nor2_2
XFILLER_102_516 VGND VGND VPWR VPWR sky130_fd_sc_hd__decap_3
XFILLER_114_365 VGND VGND VPWR VPWR sky130_fd_sc_hd__fill_2
XFILLER_87_205 VGND VGND VPWR VPWR sky130_fd_sc_hd__decap_3
X_5264_ _5264_/A0 _4997_/X _5274_/S VGND VGND VPWR VPWR _7198_/D sky130_fd_sc_hd__mux2_2
XFILLER_87_249 VGND VGND VPWR VPWR sky130_fd_sc_hd__decap_3
X_7003_ _7373_/CLK _7003_/D _6283_/Y VGND VGND VPWR VPWR _7003_/Q sky130_fd_sc_hd__dfrtp_2
X_4215_ _7260_/Q _4356_/A2 _4212_/X _4214_/X VGND VGND VPWR VPWR _4371_/A sky130_fd_sc_hd__a211o_2
XFILLER_28_305 VGND VGND VPWR VPWR sky130_fd_sc_hd__decap_3
X_4146_ _7234_/Q _4421_/A2 _4263_/A2 _7138_/Q VGND VGND VPWR VPWR _4146_/X sky130_fd_sc_hd__a22o_2
XFILLER_55_113 VGND VGND VPWR VPWR sky130_fd_sc_hd__decap_3
XFILLER_56_625 VGND VGND VPWR VPWR sky130_fd_sc_hd__decap_3
XFILLER_43_308 VGND VGND VPWR VPWR sky130_fd_sc_hd__decap_3
XFILLER_56_669 VGND VGND VPWR VPWR sky130_fd_sc_hd__decap_3
XFILLER_71_617 VGND VGND VPWR VPWR sky130_fd_sc_hd__decap_3
XFILLER_83_455 VGND VGND VPWR VPWR sky130_fd_sc_hd__decap_3
X_4077_ _7243_/Q _4433_/B _4434_/A2 _7115_/Q _4076_/X VGND VGND VPWR VPWR _4077_/X
+ sky130_fd_sc_hd__a221o_2
XFILLER_83_488 VGND VGND VPWR VPWR sky130_fd_sc_hd__decap_3
XFILLER_24_533 VGND VGND VPWR VPWR sky130_fd_sc_hd__decap_3
XFILLER_24_577 VGND VGND VPWR VPWR sky130_fd_sc_hd__decap_3
XFILLER_51_396 VGND VGND VPWR VPWR sky130_fd_sc_hd__decap_3
X_4979_ _4979_/A0 _4978_/X _4979_/S VGND VGND VPWR VPWR _7263_/D sky130_fd_sc_hd__mux2_2
Xclkload3 clkload3/A VGND VGND VPWR VPWR clkload3/Y sky130_fd_sc_hd__bufinv_16
X_6718_ _7390_/CLK _6718_/D VGND VGND VPWR VPWR _6718_/Q sky130_fd_sc_hd__dfxtp_2
XFILLER_109_137 VGND VGND VPWR VPWR sky130_fd_sc_hd__decap_3
X_6649_ _6649_/A VGND VGND VPWR VPWR _6649_/Y sky130_fd_sc_hd__inv_2
XFILLER_118_660 VGND VGND VPWR VPWR sky130_fd_sc_hd__decap_3
XTAP_TAPCELL_ROW_115_1700 VGND VPWR sky130_fd_sc_hd__tapvpwrvgnd_1
XFILLER_105_310 VGND VGND VPWR VPWR sky130_fd_sc_hd__decap_3
XFILLER_118_693 VGND VGND VPWR VPWR sky130_fd_sc_hd__decap_3
XFILLER_3_426 VGND VGND VPWR VPWR sky130_fd_sc_hd__fill_1
XFILLER_105_343 VGND VGND VPWR VPWR sky130_fd_sc_hd__decap_3
XFILLER_117_181 VGND VGND VPWR VPWR sky130_fd_sc_hd__fill_2
XFILLER_79_706 VGND VGND VPWR VPWR sky130_fd_sc_hd__decap_3
XFILLER_78_227 VGND VGND VPWR VPWR sky130_fd_sc_hd__decap_3
Xoutput580 _5662_/C VGND VGND VPWR VPWR alu_result_out[17] sky130_fd_sc_hd__clkdlybuf4s25_1
XFILLER_59_430 VGND VGND VPWR VPWR sky130_fd_sc_hd__decap_3
Xoutput591 _5652_/Y VGND VGND VPWR VPWR alu_result_out[27] sky130_fd_sc_hd__clkdlybuf4s25_1
XFILLER_115_51 VGND VGND VPWR VPWR sky130_fd_sc_hd__decap_3
XFILLER_59_452 VGND VGND VPWR VPWR sky130_fd_sc_hd__decap_3
XFILLER_115_84 VGND VGND VPWR VPWR sky130_fd_sc_hd__decap_3
XFILLER_19_316 VGND VGND VPWR VPWR sky130_fd_sc_hd__decap_3
XFILLER_47_647 VGND VGND VPWR VPWR sky130_fd_sc_hd__decap_3
XFILLER_59_496 VGND VGND VPWR VPWR sky130_fd_sc_hd__decap_3
XFILLER_86_282 VGND VGND VPWR VPWR sky130_fd_sc_hd__decap_3
XFILLER_27_371 VGND VGND VPWR VPWR sky130_fd_sc_hd__decap_3
XFILLER_46_168 VGND VGND VPWR VPWR sky130_fd_sc_hd__decap_3
XFILLER_61_116 VGND VGND VPWR VPWR sky130_fd_sc_hd__decap_3
XFILLER_62_617 VGND VGND VPWR VPWR sky130_fd_sc_hd__decap_3
XTAP_TAPCELL_ROW_45_826 VGND VPWR sky130_fd_sc_hd__tapvpwrvgnd_1
XTAP_TAPCELL_ROW_45_815 VGND VPWR sky130_fd_sc_hd__tapvpwrvgnd_1
XFILLER_15_522 VGND VGND VPWR VPWR sky130_fd_sc_hd__decap_3
XFILLER_55_691 VGND VGND VPWR VPWR sky130_fd_sc_hd__decap_3
XFILLER_61_149 VGND VGND VPWR VPWR sky130_fd_sc_hd__decap_3
XFILLER_70_672 VGND VGND VPWR VPWR sky130_fd_sc_hd__decap_3
XFILLER_91_43 VGND VGND VPWR VPWR sky130_fd_sc_hd__decap_3
XFILLER_91_65 VGND VGND VPWR VPWR sky130_fd_sc_hd__decap_3
XFILLER_15_599 VGND VGND VPWR VPWR sky130_fd_sc_hd__decap_3
XFILLER_91_98 VGND VGND VPWR VPWR sky130_fd_sc_hd__decap_3
XTAP_TAPCELL_ROW_25_572 VGND VPWR sky130_fd_sc_hd__tapvpwrvgnd_1
XFILLER_116_619 VGND VGND VPWR VPWR sky130_fd_sc_hd__decap_3
XFILLER_6_220 VGND VGND VPWR VPWR sky130_fd_sc_hd__decap_3
XFILLER_6_253 VGND VGND VPWR VPWR sky130_fd_sc_hd__decap_3
Xwire663 _3749_/Y VGND VGND VPWR VPWR wire663/X sky130_fd_sc_hd__clkbuf_2
XTAP_TAPCELL_ROW_77_1216 VGND VPWR sky130_fd_sc_hd__tapvpwrvgnd_1
XFILLER_109_671 VGND VGND VPWR VPWR sky130_fd_sc_hd__fill_1
XFILLER_109_682 VGND VGND VPWR VPWR sky130_fd_sc_hd__decap_3
XFILLER_115_118 VGND VGND VPWR VPWR sky130_fd_sc_hd__fill_1
XFILLER_108_181 VGND VGND VPWR VPWR sky130_fd_sc_hd__decap_3
XFILLER_40_91 VGND VGND VPWR VPWR sky130_fd_sc_hd__decap_3
XFILLER_41_6 VGND VGND VPWR VPWR sky130_fd_sc_hd__decap_3
XFILLER_2_492 VGND VGND VPWR VPWR sky130_fd_sc_hd__decap_3
XFILLER_85_709 VGND VGND VPWR VPWR sky130_fd_sc_hd__decap_3
XFILLER_97_547 VGND VGND VPWR VPWR sky130_fd_sc_hd__decap_3
XFILLER_111_368 VGND VGND VPWR VPWR sky130_fd_sc_hd__decap_3
XFILLER_37_102 VGND VGND VPWR VPWR sky130_fd_sc_hd__decap_3
XFILLER_37_113 VGND VGND VPWR VPWR sky130_fd_sc_hd__decap_3
XFILLER_37_124 VGND VGND VPWR VPWR sky130_fd_sc_hd__decap_3
XFILLER_38_625 VGND VGND VPWR VPWR sky130_fd_sc_hd__decap_3
XFILLER_65_400 VGND VGND VPWR VPWR sky130_fd_sc_hd__fill_2
XFILLER_38_669 VGND VGND VPWR VPWR sky130_fd_sc_hd__decap_3
XFILLER_65_444 VGND VGND VPWR VPWR sky130_fd_sc_hd__decap_3
XFILLER_65_455 VGND VGND VPWR VPWR sky130_fd_sc_hd__decap_3
XFILLER_92_241 VGND VGND VPWR VPWR sky130_fd_sc_hd__decap_3
XTAP_TAPCELL_ROW_88_1356 VGND VPWR sky130_fd_sc_hd__tapvpwrvgnd_1
XFILLER_18_360 VGND VGND VPWR VPWR sky130_fd_sc_hd__decap_3
XFILLER_18_371 VGND VGND VPWR VPWR sky130_fd_sc_hd__decap_3
XFILLER_1_85 VGND VGND VPWR VPWR sky130_fd_sc_hd__fill_1
XFILLER_37_179 VGND VGND VPWR VPWR sky130_fd_sc_hd__decap_3
XFILLER_53_617 VGND VGND VPWR VPWR sky130_fd_sc_hd__decap_3
XFILLER_65_488 VGND VGND VPWR VPWR sky130_fd_sc_hd__decap_3
XFILLER_52_138 VGND VGND VPWR VPWR sky130_fd_sc_hd__fill_2
XFILLER_61_650 VGND VGND VPWR VPWR sky130_fd_sc_hd__decap_3
XFILLER_80_469 VGND VGND VPWR VPWR sky130_fd_sc_hd__decap_3
XFILLER_33_396 VGND VGND VPWR VPWR sky130_fd_sc_hd__decap_3
XFILLER_61_694 VGND VGND VPWR VPWR sky130_fd_sc_hd__decap_3
X_4833_ _7001_/Q _4687_/B _4777_/A VGND VGND VPWR VPWR _4834_/B sky130_fd_sc_hd__o21ai_2
XFILLER_119_402 VGND VGND VPWR VPWR sky130_fd_sc_hd__decap_3
X_4764_ _4938_/A _4764_/B VGND VGND VPWR VPWR _4765_/A sky130_fd_sc_hd__nor2_2
XFILLER_119_435 VGND VGND VPWR VPWR sky130_fd_sc_hd__decap_3
X_6503_ _6535_/A VGND VGND VPWR VPWR _6503_/Y sky130_fd_sc_hd__inv_2
X_6434_ _6635_/A VGND VGND VPWR VPWR _6434_/Y sky130_fd_sc_hd__inv_2
X_4695_ _7008_/Q _4728_/A _4694_/Y _5647_/A VGND VGND VPWR VPWR _4695_/X sky130_fd_sc_hd__a211o_2
XTAP_TAPCELL_ROW_99_1496 VGND VPWR sky130_fd_sc_hd__tapvpwrvgnd_1
XFILLER_106_107 VGND VGND VPWR VPWR sky130_fd_sc_hd__decap_3
XFILLER_115_641 VGND VGND VPWR VPWR sky130_fd_sc_hd__decap_3
X_6365_ _6649_/A VGND VGND VPWR VPWR _6365_/Y sky130_fd_sc_hd__inv_2
X_3577_ _7060_/Q _4305_/B VGND VGND VPWR VPWR _3591_/C sky130_fd_sc_hd__nor2_2
XFILLER_115_685 VGND VGND VPWR VPWR sky130_fd_sc_hd__decap_3
X_6296_ _6570_/A VGND VGND VPWR VPWR _6296_/Y sky130_fd_sc_hd__inv_2
XFILLER_0_429 VGND VGND VPWR VPWR sky130_fd_sc_hd__decap_3
XFILLER_114_195 VGND VGND VPWR VPWR sky130_fd_sc_hd__fill_1
XFILLER_88_547 VGND VGND VPWR VPWR sky130_fd_sc_hd__decap_3
X_5247_ _5247_/A0 _4864_/X _5272_/S VGND VGND VPWR VPWR _7206_/D sky130_fd_sc_hd__mux2_2
XTAP_TAPCELL_ROW_110_1630 VGND VPWR sky130_fd_sc_hd__tapvpwrvgnd_1
XFILLER_102_357 VGND VGND VPWR VPWR sky130_fd_sc_hd__decap_3
XFILLER_29_603 VGND VGND VPWR VPWR sky130_fd_sc_hd__decap_3
XFILLER_75_208 VGND VGND VPWR VPWR sky130_fd_sc_hd__decap_3
XFILLER_88_569 VGND VGND VPWR VPWR sky130_fd_sc_hd__decap_3
XFILLER_29_647 VGND VGND VPWR VPWR sky130_fd_sc_hd__decap_3
XFILLER_56_433 VGND VGND VPWR VPWR sky130_fd_sc_hd__decap_3
X_4129_ _7299_/Q _4419_/A2 _4419_/B1 _7363_/Q _4429_/C1 VGND VGND VPWR VPWR _4129_/X
+ sky130_fd_sc_hd__a221o_2
XFILLER_28_168 VGND VGND VPWR VPWR sky130_fd_sc_hd__decap_3
XFILLER_44_628 VGND VGND VPWR VPWR sky130_fd_sc_hd__decap_3
XFILLER_56_488 VGND VGND VPWR VPWR sky130_fd_sc_hd__decap_3
XFILLER_83_263 VGND VGND VPWR VPWR sky130_fd_sc_hd__decap_3
XFILLER_37_691 VGND VGND VPWR VPWR sky130_fd_sc_hd__decap_3
XFILLER_43_138 VGND VGND VPWR VPWR sky130_fd_sc_hd__decap_3
XFILLER_45_69 VGND VGND VPWR VPWR sky130_fd_sc_hd__fill_1
XFILLER_71_458 VGND VGND VPWR VPWR sky130_fd_sc_hd__decap_3
XFILLER_24_341 VGND VGND VPWR VPWR sky130_fd_sc_hd__decap_3
XFILLER_52_672 VGND VGND VPWR VPWR sky130_fd_sc_hd__decap_3
XFILLER_12_536 VGND VGND VPWR VPWR sky130_fd_sc_hd__decap_3
XFILLER_24_374 VGND VGND VPWR VPWR sky130_fd_sc_hd__decap_3
XTAP_TAPCELL_ROW_61_1017 VGND VPWR sky130_fd_sc_hd__tapvpwrvgnd_1
XFILLER_12_569 VGND VGND VPWR VPWR sky130_fd_sc_hd__decap_3
XFILLER_51_193 VGND VGND VPWR VPWR sky130_fd_sc_hd__fill_2
XFILLER_61_57 VGND VGND VPWR VPWR sky130_fd_sc_hd__fill_1
XTAP_TAPCELL_ROW_22_531 VGND VPWR sky130_fd_sc_hd__tapvpwrvgnd_1
XTAP_TAPCELL_ROW_50_884 VGND VPWR sky130_fd_sc_hd__tapvpwrvgnd_1
XFILLER_20_580 VGND VGND VPWR VPWR sky130_fd_sc_hd__decap_3
XFILLER_4_713 VGND VGND VPWR VPWR sky130_fd_sc_hd__fill_1
XFILLER_105_162 VGND VGND VPWR VPWR sky130_fd_sc_hd__decap_3
XFILLER_106_663 VGND VGND VPWR VPWR sky130_fd_sc_hd__decap_3
XFILLER_3_267 VGND VGND VPWR VPWR sky130_fd_sc_hd__decap_3
XFILLER_79_514 VGND VGND VPWR VPWR sky130_fd_sc_hd__decap_3
XFILLER_105_184 VGND VGND VPWR VPWR sky130_fd_sc_hd__decap_3
XFILLER_106_696 VGND VGND VPWR VPWR sky130_fd_sc_hd__decap_3
XTAP_TAPCELL_ROW_72_1157 VGND VPWR sky130_fd_sc_hd__tapvpwrvgnd_1
XFILLER_67_709 VGND VGND VPWR VPWR sky130_fd_sc_hd__decap_3
XFILLER_86_32 VGND VGND VPWR VPWR sky130_fd_sc_hd__decap_3
XFILLER_19_113 VGND VGND VPWR VPWR sky130_fd_sc_hd__decap_3
XFILLER_47_411 VGND VGND VPWR VPWR sky130_fd_sc_hd__fill_1
XFILLER_86_76 VGND VGND VPWR VPWR sky130_fd_sc_hd__decap_3
XFILLER_19_92 VGND VGND VPWR VPWR sky130_fd_sc_hd__decap_3
XFILLER_35_606 VGND VGND VPWR VPWR sky130_fd_sc_hd__decap_3
XFILLER_35_617 VGND VGND VPWR VPWR sky130_fd_sc_hd__decap_3
XFILLER_90_701 VGND VGND VPWR VPWR sky130_fd_sc_hd__decap_3
XTAP_TAPCELL_ROW_58_984 VGND VPWR sky130_fd_sc_hd__tapvpwrvgnd_1
XFILLER_62_436 VGND VGND VPWR VPWR sky130_fd_sc_hd__decap_3
XFILLER_15_330 VGND VGND VPWR VPWR sky130_fd_sc_hd__decap_3
XFILLER_43_650 VGND VGND VPWR VPWR sky130_fd_sc_hd__decap_3
XFILLER_15_396 VGND VGND VPWR VPWR sky130_fd_sc_hd__decap_3
XFILLER_43_694 VGND VGND VPWR VPWR sky130_fd_sc_hd__decap_3
XFILLER_70_491 VGND VGND VPWR VPWR sky130_fd_sc_hd__decap_3
XTAP_TAPCELL_ROW_83_1297 VGND VPWR sky130_fd_sc_hd__tapvpwrvgnd_1
XFILLER_30_333 VGND VGND VPWR VPWR sky130_fd_sc_hd__decap_3
XFILLER_42_193 VGND VGND VPWR VPWR sky130_fd_sc_hd__decap_3
XFILLER_30_388 VGND VGND VPWR VPWR sky130_fd_sc_hd__decap_3
XFILLER_11_591 VGND VGND VPWR VPWR sky130_fd_sc_hd__decap_3
XFILLER_7_551 VGND VGND VPWR VPWR sky130_fd_sc_hd__decap_3
X_3500_ _4460_/A _4460_/B _3541_/B VGND VGND VPWR VPWR _3500_/Y sky130_fd_sc_hd__a21oi_2
XFILLER_116_438 VGND VGND VPWR VPWR sky130_fd_sc_hd__decap_3
XFILLER_7_573 VGND VGND VPWR VPWR sky130_fd_sc_hd__decap_3
X_4480_ _4480_/A0 _4546_/A _4488_/S VGND VGND VPWR VPWR _7339_/D sky130_fd_sc_hd__mux2_2
X_3362_ _6979_/Q _6983_/Q _5129_/A VGND VGND VPWR VPWR _3362_/X sky130_fd_sc_hd__or3b_2
XFILLER_112_622 VGND VGND VPWR VPWR sky130_fd_sc_hd__decap_3
X_5101_ _5101_/A _5101_/B VGND VGND VPWR VPWR _5101_/Y sky130_fd_sc_hd__nor2_2
XFILLER_112_666 VGND VGND VPWR VPWR sky130_fd_sc_hd__decap_3
XFILLER_97_366 VGND VGND VPWR VPWR sky130_fd_sc_hd__decap_3
Xhold1207 _7120_/Q VGND VGND VPWR VPWR _5427_/A0 sky130_fd_sc_hd__dlygate4sd3_1
XFILLER_111_165 VGND VGND VPWR VPWR sky130_fd_sc_hd__decap_3
XFILLER_112_699 VGND VGND VPWR VPWR sky130_fd_sc_hd__fill_1
XFILLER_85_539 VGND VGND VPWR VPWR sky130_fd_sc_hd__fill_1
Xhold1218 _7135_/Q VGND VGND VPWR VPWR _5396_/A0 sky130_fd_sc_hd__dlygate4sd3_1
Xhold1229 _7162_/Q VGND VGND VPWR VPWR _5338_/A0 sky130_fd_sc_hd__dlygate4sd3_1
X_5032_ _5032_/A _5032_/B VGND VGND VPWR VPWR _5032_/Y sky130_fd_sc_hd__xnor2_2
XFILLER_38_444 VGND VGND VPWR VPWR sky130_fd_sc_hd__decap_3
Xsingle_cycle_cpu_681 VGND VGND VPWR VPWR instruction_out[1] single_cycle_cpu_681/LO
+ sky130_fd_sc_hd__conb_1
XFILLER_25_105 VGND VGND VPWR VPWR sky130_fd_sc_hd__decap_3
XFILLER_26_628 VGND VGND VPWR VPWR sky130_fd_sc_hd__decap_3
XFILLER_38_477 VGND VGND VPWR VPWR sky130_fd_sc_hd__decap_3
XFILLER_53_414 VGND VGND VPWR VPWR sky130_fd_sc_hd__decap_3
XFILLER_65_252 VGND VGND VPWR VPWR sky130_fd_sc_hd__decap_3
XFILLER_80_200 VGND VGND VPWR VPWR sky130_fd_sc_hd__decap_3
XFILLER_81_712 VGND VGND VPWR VPWR sky130_fd_sc_hd__fill_2
XFILLER_93_561 VGND VGND VPWR VPWR sky130_fd_sc_hd__decap_3
XFILLER_19_691 VGND VGND VPWR VPWR sky130_fd_sc_hd__decap_3
XFILLER_25_116 VGND VGND VPWR VPWR sky130_fd_sc_hd__decap_3
XFILLER_53_436 VGND VGND VPWR VPWR sky130_fd_sc_hd__decap_3
XFILLER_80_222 VGND VGND VPWR VPWR sky130_fd_sc_hd__decap_3
X_6983_ _6983_/CLK _6983_/D _6263_/Y VGND VGND VPWR VPWR _6983_/Q sky130_fd_sc_hd__dfrtp_2
XTAP_TAPCELL_ROW_0_259 VGND VPWR sky130_fd_sc_hd__tapvpwrvgnd_1
XTAP_TAPCELL_ROW_0_248 VGND VPWR sky130_fd_sc_hd__tapvpwrvgnd_1
XFILLER_41_609 VGND VGND VPWR VPWR sky130_fd_sc_hd__decap_3
XFILLER_21_300 VGND VGND VPWR VPWR sky130_fd_sc_hd__fill_2
XFILLER_34_672 VGND VGND VPWR VPWR sky130_fd_sc_hd__decap_3
XFILLER_61_480 VGND VGND VPWR VPWR sky130_fd_sc_hd__decap_3
XFILLER_21_333 VGND VGND VPWR VPWR sky130_fd_sc_hd__decap_3
XFILLER_21_355 VGND VGND VPWR VPWR sky130_fd_sc_hd__decap_3
X_4816_ _4970_/A1 _4652_/A _4813_/A _5033_/B2 VGND VGND VPWR VPWR _4816_/X sky130_fd_sc_hd__a22o_2
XFILLER_119_210 VGND VGND VPWR VPWR sky130_fd_sc_hd__decap_3
XFILLER_21_377 VGND VGND VPWR VPWR sky130_fd_sc_hd__fill_2
X_4747_ _4739_/Y _4740_/X _4743_/X _4746_/X VGND VGND VPWR VPWR _5664_/B sky130_fd_sc_hd__o211a_2
X_4678_ _6988_/Q _4674_/X _5045_/B _5036_/A VGND VGND VPWR VPWR _5014_/B sky130_fd_sc_hd__a31o_2
XFILLER_107_449 VGND VGND VPWR VPWR sky130_fd_sc_hd__decap_3
X_7397_ _7403_/CLK _7397_/D _6677_/Y VGND VGND VPWR VPWR _7397_/Q sky130_fd_sc_hd__dfrtp_2
X_6417_ _6645_/A VGND VGND VPWR VPWR _6417_/Y sky130_fd_sc_hd__inv_2
X_3629_ _3629_/A VGND VGND VPWR VPWR _3629_/Y sky130_fd_sc_hd__inv_2
XFILLER_115_460 VGND VGND VPWR VPWR sky130_fd_sc_hd__decap_3
X_6348_ _6671_/A VGND VGND VPWR VPWR _6348_/Y sky130_fd_sc_hd__inv_2
XFILLER_0_237 VGND VGND VPWR VPWR sky130_fd_sc_hd__decap_3
XFILLER_103_644 VGND VGND VPWR VPWR sky130_fd_sc_hd__decap_3
XTAP_TAPCELL_ROW_8_359 VGND VPWR sky130_fd_sc_hd__tapvpwrvgnd_1
XFILLER_102_121 VGND VGND VPWR VPWR sky130_fd_sc_hd__decap_3
XFILLER_49_709 VGND VGND VPWR VPWR sky130_fd_sc_hd__decap_3
XFILLER_88_355 VGND VGND VPWR VPWR sky130_fd_sc_hd__decap_3
XFILLER_88_377 VGND VGND VPWR VPWR sky130_fd_sc_hd__decap_3
X_6279_ _6288_/A VGND VGND VPWR VPWR _6279_/Y sky130_fd_sc_hd__inv_2
XFILLER_102_165 VGND VGND VPWR VPWR sky130_fd_sc_hd__decap_3
XFILLER_103_688 VGND VGND VPWR VPWR sky130_fd_sc_hd__decap_3
XFILLER_29_411 VGND VGND VPWR VPWR sky130_fd_sc_hd__decap_3
XFILLER_48_219 VGND VGND VPWR VPWR sky130_fd_sc_hd__decap_3
XFILLER_17_617 VGND VGND VPWR VPWR sky130_fd_sc_hd__decap_3
XFILLER_72_701 VGND VGND VPWR VPWR sky130_fd_sc_hd__decap_3
XTAP_TAPCELL_ROW_27_601 VGND VPWR sky130_fd_sc_hd__tapvpwrvgnd_1
XFILLER_112_41 VGND VGND VPWR VPWR sky130_fd_sc_hd__decap_3
XFILLER_44_436 VGND VGND VPWR VPWR sky130_fd_sc_hd__fill_1
XFILLER_56_296 VGND VGND VPWR VPWR sky130_fd_sc_hd__decap_3
XFILLER_71_211 VGND VGND VPWR VPWR sky130_fd_sc_hd__decap_3
XTAP_TAPCELL_ROW_55_943 VGND VPWR sky130_fd_sc_hd__tapvpwrvgnd_1
XFILLER_112_74 VGND VGND VPWR VPWR sky130_fd_sc_hd__decap_3
XFILLER_112_85 VGND VGND VPWR VPWR sky130_fd_sc_hd__fill_2
XFILLER_16_149 VGND VGND VPWR VPWR sky130_fd_sc_hd__decap_3
XFILLER_25_650 VGND VGND VPWR VPWR sky130_fd_sc_hd__decap_3
XFILLER_24_171 VGND VGND VPWR VPWR sky130_fd_sc_hd__decap_3
XFILLER_25_694 VGND VGND VPWR VPWR sky130_fd_sc_hd__decap_3
XFILLER_40_631 VGND VGND VPWR VPWR sky130_fd_sc_hd__decap_3
XFILLER_40_675 VGND VGND VPWR VPWR sky130_fd_sc_hd__decap_3
XFILLER_8_315 VGND VGND VPWR VPWR sky130_fd_sc_hd__decap_3
XFILLER_12_399 VGND VGND VPWR VPWR sky130_fd_sc_hd__decap_3
XFILLER_21_60 VGND VGND VPWR VPWR sky130_fd_sc_hd__decap_3
XFILLER_4_521 VGND VGND VPWR VPWR sky130_fd_sc_hd__decap_3
XFILLER_106_460 VGND VGND VPWR VPWR sky130_fd_sc_hd__decap_3
XFILLER_4_554 VGND VGND VPWR VPWR sky130_fd_sc_hd__decap_3
XFILLER_98_108 VGND VGND VPWR VPWR sky130_fd_sc_hd__decap_3
XFILLER_106_482 VGND VGND VPWR VPWR sky130_fd_sc_hd__decap_3
XFILLER_4_587 VGND VGND VPWR VPWR sky130_fd_sc_hd__fill_1
XFILLER_97_97 VGND VGND VPWR VPWR sky130_fd_sc_hd__decap_3
XFILLER_67_539 VGND VGND VPWR VPWR sky130_fd_sc_hd__decap_3
XFILLER_94_358 VGND VGND VPWR VPWR sky130_fd_sc_hd__decap_3
XFILLER_47_252 VGND VGND VPWR VPWR sky130_fd_sc_hd__decap_3
XFILLER_63_712 VGND VGND VPWR VPWR sky130_fd_sc_hd__fill_2
XTAP_TAPCELL_ROW_85_1315 VGND VPWR sky130_fd_sc_hd__tapvpwrvgnd_1
XFILLER_62_211 VGND VGND VPWR VPWR sky130_fd_sc_hd__decap_3
XTAP_TAPCELL_ROW_85_1326 VGND VPWR sky130_fd_sc_hd__tapvpwrvgnd_1
XFILLER_23_609 VGND VGND VPWR VPWR sky130_fd_sc_hd__decap_3
XFILLER_50_406 VGND VGND VPWR VPWR sky130_fd_sc_hd__decap_3
XFILLER_16_672 VGND VGND VPWR VPWR sky130_fd_sc_hd__decap_3
XFILLER_31_620 VGND VGND VPWR VPWR sky130_fd_sc_hd__decap_3
XFILLER_15_193 VGND VGND VPWR VPWR sky130_fd_sc_hd__decap_3
XFILLER_31_653 VGND VGND VPWR VPWR sky130_fd_sc_hd__decap_3
XFILLER_43_491 VGND VGND VPWR VPWR sky130_fd_sc_hd__fill_1
Xclkbuf_0_clk clk VGND VGND VPWR VPWR clkbuf_0_clk/X sky130_fd_sc_hd__clkbuf_16
X_5650_ _5650_/A VGND VGND VPWR VPWR _5650_/Y sky130_fd_sc_hd__inv_2
XFILLER_30_141 VGND VGND VPWR VPWR sky130_fd_sc_hd__fill_2
XFILLER_30_152 VGND VGND VPWR VPWR sky130_fd_sc_hd__decap_3
XFILLER_31_697 VGND VGND VPWR VPWR sky130_fd_sc_hd__decap_3
X_4601_ _4601_/A0 _5157_/A0 _4601_/S VGND VGND VPWR VPWR _7280_/D sky130_fd_sc_hd__mux2_2
XFILLER_117_703 VGND VGND VPWR VPWR sky130_fd_sc_hd__decap_3
XFILLER_30_174 VGND VGND VPWR VPWR sky130_fd_sc_hd__decap_3
X_5581_ _5581_/A0 _5069_/X _5581_/S VGND VGND VPWR VPWR _7038_/D sky130_fd_sc_hd__mux2_2
X_7320_ _7354_/CLK _7320_/D _6600_/Y VGND VGND VPWR VPWR _7320_/Q sky130_fd_sc_hd__dfrtp_2
X_4532_ _4532_/A0 _7281_/Q _4532_/S VGND VGND VPWR VPWR _4532_/X sky130_fd_sc_hd__mux2_2
X_7251_ _7345_/CLK _7251_/D _6531_/Y VGND VGND VPWR VPWR _7251_/Q sky130_fd_sc_hd__dfrtp_2
X_4463_ _4460_/Y _3541_/B _5057_/A _4462_/Y VGND VGND VPWR VPWR _4463_/X sky130_fd_sc_hd__a22o_2
XTAP_TAPCELL_ROW_96_1455 VGND VPWR sky130_fd_sc_hd__tapvpwrvgnd_1
XFILLER_89_119 VGND VGND VPWR VPWR sky130_fd_sc_hd__decap_3
X_3414_ _3421_/C VGND VGND VPWR VPWR _3449_/C sky130_fd_sc_hd__inv_4
XFILLER_98_642 VGND VGND VPWR VPWR sky130_fd_sc_hd__fill_2
X_7182_ _7374_/CLK _7182_/D _6462_/Y VGND VGND VPWR VPWR _7182_/Q sky130_fd_sc_hd__dfrtp_2
X_4394_ _4394_/A _4394_/B _4393_/X VGND VGND VPWR VPWR _4444_/B sky130_fd_sc_hd__or3b_2
XPHY_EDGE_ROW_15_Right_15 VGND VGND VPWR VPWR sky130_fd_sc_hd__decap_3
XFILLER_98_675 VGND VGND VPWR VPWR sky130_fd_sc_hd__decap_3
X_3345_ _4606_/A _4677_/B VGND VGND VPWR VPWR _3346_/A sky130_fd_sc_hd__nor2_4
XTAP_TAPCELL_ROW_5_318 VGND VPWR sky130_fd_sc_hd__tapvpwrvgnd_1
XFILLER_100_614 VGND VGND VPWR VPWR sky130_fd_sc_hd__decap_3
XFILLER_112_474 VGND VGND VPWR VPWR sky130_fd_sc_hd__fill_2
XFILLER_112_496 VGND VGND VPWR VPWR sky130_fd_sc_hd__decap_3
XFILLER_58_528 VGND VGND VPWR VPWR sky130_fd_sc_hd__fill_1
XFILLER_58_539 VGND VGND VPWR VPWR sky130_fd_sc_hd__decap_3
XFILLER_85_314 VGND VGND VPWR VPWR sky130_fd_sc_hd__decap_3
Xhold1004 _7078_/Q VGND VGND VPWR VPWR _7078_/D sky130_fd_sc_hd__dlygate4sd3_1
Xhold1015 _6697_/Q VGND VGND VPWR VPWR _5695_/A1 sky130_fd_sc_hd__dlygate4sd3_1
XFILLER_100_669 VGND VGND VPWR VPWR sky130_fd_sc_hd__decap_3
Xhold1026 _6716_/Q VGND VGND VPWR VPWR _5733_/A1 sky130_fd_sc_hd__dlygate4sd3_1
Xhold1037 _7029_/Q VGND VGND VPWR VPWR _5597_/A1 sky130_fd_sc_hd__dlygate4sd3_1
Xhold1048 _7210_/Q VGND VGND VPWR VPWR _5240_/B2 sky130_fd_sc_hd__dlygate4sd3_1
X_5015_ _5579_/S _5015_/B _5015_/C VGND VGND VPWR VPWR _5015_/X sky130_fd_sc_hd__and3_2
XFILLER_38_241 VGND VGND VPWR VPWR sky130_fd_sc_hd__decap_3
XFILLER_54_701 VGND VGND VPWR VPWR sky130_fd_sc_hd__decap_3
XFILLER_66_572 VGND VGND VPWR VPWR sky130_fd_sc_hd__decap_3
Xhold1059 _7389_/Q VGND VGND VPWR VPWR _3822_/A1 sky130_fd_sc_hd__dlygate4sd3_1
XFILLER_53_200 VGND VGND VPWR VPWR sky130_fd_sc_hd__decap_3
XFILLER_53_222 VGND VGND VPWR VPWR sky130_fd_sc_hd__fill_2
XFILLER_26_458 VGND VGND VPWR VPWR sky130_fd_sc_hd__decap_3
XFILLER_53_255 VGND VGND VPWR VPWR sky130_fd_sc_hd__decap_3
X_6966_ clkload3/A _6966_/D VGND VGND VPWR VPWR _6966_/Q sky130_fd_sc_hd__dfxtp_2
XTAP_TAPCELL_ROW_52_902 VGND VPWR sky130_fd_sc_hd__tapvpwrvgnd_1
XPHY_EDGE_ROW_24_Right_24 VGND VGND VPWR VPWR sky130_fd_sc_hd__decap_3
XFILLER_53_299 VGND VGND VPWR VPWR sky130_fd_sc_hd__decap_3
XFILLER_81_586 VGND VGND VPWR VPWR sky130_fd_sc_hd__fill_2
XTAP_TAPCELL_ROW_52_913 VGND VPWR sky130_fd_sc_hd__tapvpwrvgnd_1
XTAP_TAPCELL_ROW_105_1573 VGND VPWR sky130_fd_sc_hd__tapvpwrvgnd_1
XFILLER_22_631 VGND VGND VPWR VPWR sky130_fd_sc_hd__decap_3
XFILLER_34_480 VGND VGND VPWR VPWR sky130_fd_sc_hd__decap_3
X_6897_ _6942_/CLK _6897_/D VGND VGND VPWR VPWR _6897_/Q sky130_fd_sc_hd__dfxtp_2
XFILLER_22_675 VGND VGND VPWR VPWR sky130_fd_sc_hd__decap_3
XFILLER_5_329 VGND VGND VPWR VPWR sky130_fd_sc_hd__decap_3
XFILLER_107_213 VGND VGND VPWR VPWR sky130_fd_sc_hd__fill_1
XFILLER_107_246 VGND VGND VPWR VPWR sky130_fd_sc_hd__decap_3
XFILLER_107_268 VGND VGND VPWR VPWR sky130_fd_sc_hd__decap_3
XFILLER_1_502 VGND VGND VPWR VPWR sky130_fd_sc_hd__fill_2
XPHY_EDGE_ROW_33_Right_33 VGND VGND VPWR VPWR sky130_fd_sc_hd__decap_3
XFILLER_107_41 VGND VGND VPWR VPWR sky130_fd_sc_hd__decap_3
XFILLER_1_535 VGND VGND VPWR VPWR sky130_fd_sc_hd__decap_3
XFILLER_89_620 VGND VGND VPWR VPWR sky130_fd_sc_hd__decap_3
Xhold860 _6846_/Q VGND VGND VPWR VPWR _6846_/D sky130_fd_sc_hd__dlygate4sd3_1
Xhold871 _6907_/Q VGND VGND VPWR VPWR _6907_/D sky130_fd_sc_hd__dlygate4sd3_1
Xhold882 _6870_/Q VGND VGND VPWR VPWR _6870_/D sky130_fd_sc_hd__dlygate4sd3_1
XFILLER_103_441 VGND VGND VPWR VPWR sky130_fd_sc_hd__decap_3
XFILLER_103_452 VGND VGND VPWR VPWR sky130_fd_sc_hd__decap_3
XFILLER_107_63 VGND VGND VPWR VPWR sky130_fd_sc_hd__decap_3
XFILLER_88_141 VGND VGND VPWR VPWR sky130_fd_sc_hd__decap_3
XFILLER_89_653 VGND VGND VPWR VPWR sky130_fd_sc_hd__decap_3
Xhold893 _6910_/Q VGND VGND VPWR VPWR _6910_/D sky130_fd_sc_hd__dlygate4sd3_1
XFILLER_107_96 VGND VGND VPWR VPWR sky130_fd_sc_hd__decap_3
XFILLER_1_579 VGND VGND VPWR VPWR sky130_fd_sc_hd__decap_3
XFILLER_49_517 VGND VGND VPWR VPWR sky130_fd_sc_hd__decap_3
XFILLER_88_174 VGND VGND VPWR VPWR sky130_fd_sc_hd__decap_3
XFILLER_89_697 VGND VGND VPWR VPWR sky130_fd_sc_hd__decap_3
XFILLER_67_67 VGND VGND VPWR VPWR sky130_fd_sc_hd__decap_3
XFILLER_29_252 VGND VGND VPWR VPWR sky130_fd_sc_hd__decap_3
XFILLER_45_712 VGND VGND VPWR VPWR sky130_fd_sc_hd__fill_2
XFILLER_57_561 VGND VGND VPWR VPWR sky130_fd_sc_hd__fill_2
XFILLER_64_509 VGND VGND VPWR VPWR sky130_fd_sc_hd__decap_3
XFILLER_91_306 VGND VGND VPWR VPWR sky130_fd_sc_hd__decap_3
XFILLER_29_296 VGND VGND VPWR VPWR sky130_fd_sc_hd__fill_1
XFILLER_44_200 VGND VGND VPWR VPWR sky130_fd_sc_hd__decap_3
XFILLER_72_520 VGND VGND VPWR VPWR sky130_fd_sc_hd__fill_2
XFILLER_83_11 VGND VGND VPWR VPWR sky130_fd_sc_hd__fill_1
XFILLER_83_44 VGND VGND VPWR VPWR sky130_fd_sc_hd__decap_3
XFILLER_84_380 VGND VGND VPWR VPWR sky130_fd_sc_hd__fill_2
XPHY_EDGE_ROW_42_Right_42 VGND VGND VPWR VPWR sky130_fd_sc_hd__decap_3
XFILLER_32_406 VGND VGND VPWR VPWR sky130_fd_sc_hd__decap_3
XFILLER_60_704 VGND VGND VPWR VPWR sky130_fd_sc_hd__decap_3
XFILLER_72_542 VGND VGND VPWR VPWR sky130_fd_sc_hd__decap_3
XFILLER_83_66 VGND VGND VPWR VPWR sky130_fd_sc_hd__decap_3
XFILLER_13_620 VGND VGND VPWR VPWR sky130_fd_sc_hd__decap_3
XFILLER_13_653 VGND VGND VPWR VPWR sky130_fd_sc_hd__decap_3
XFILLER_16_82 VGND VGND VPWR VPWR sky130_fd_sc_hd__fill_2
XPHY_EDGE_ROW_17_Left_137 VGND VGND VPWR VPWR sky130_fd_sc_hd__decap_3
XFILLER_12_141 VGND VGND VPWR VPWR sky130_fd_sc_hd__fill_1
XFILLER_40_472 VGND VGND VPWR VPWR sky130_fd_sc_hd__decap_3
XTAP_TAPCELL_ROW_80_1256 VGND VPWR sky130_fd_sc_hd__tapvpwrvgnd_1
XTAP_TAPCELL_ROW_30_629 VGND VPWR sky130_fd_sc_hd__tapvpwrvgnd_1
XFILLER_9_635 VGND VGND VPWR VPWR sky130_fd_sc_hd__decap_3
XFILLER_12_174 VGND VGND VPWR VPWR sky130_fd_sc_hd__decap_3
XFILLER_13_697 VGND VGND VPWR VPWR sky130_fd_sc_hd__decap_3
XFILLER_40_483 VGND VGND VPWR VPWR sky130_fd_sc_hd__decap_3
XFILLER_8_134 VGND VGND VPWR VPWR sky130_fd_sc_hd__decap_3
XFILLER_9_668 VGND VGND VPWR VPWR sky130_fd_sc_hd__decap_3
XFILLER_8_156 VGND VGND VPWR VPWR sky130_fd_sc_hd__decap_3
XPHY_EDGE_ROW_51_Right_51 VGND VGND VPWR VPWR sky130_fd_sc_hd__decap_3
XFILLER_9_679 VGND VGND VPWR VPWR sky130_fd_sc_hd__decap_3
XTAP_TAPCELL_ROW_10_386 VGND VPWR sky130_fd_sc_hd__tapvpwrvgnd_1
XFILLER_99_406 VGND VGND VPWR VPWR sky130_fd_sc_hd__decap_3
XFILLER_4_362 VGND VGND VPWR VPWR sky130_fd_sc_hd__fill_2
XFILLER_4_373 VGND VGND VPWR VPWR sky130_fd_sc_hd__decap_3
XPHY_EDGE_ROW_26_Left_146 VGND VGND VPWR VPWR sky130_fd_sc_hd__decap_3
XFILLER_99_439 VGND VGND VPWR VPWR sky130_fd_sc_hd__decap_3
XFILLER_94_100 VGND VGND VPWR VPWR sky130_fd_sc_hd__decap_3
XFILLER_95_601 VGND VGND VPWR VPWR sky130_fd_sc_hd__decap_3
XFILLER_95_623 VGND VGND VPWR VPWR sky130_fd_sc_hd__decap_3
XTAP_TAPCELL_ROW_91_1396 VGND VPWR sky130_fd_sc_hd__tapvpwrvgnd_1
XFILLER_94_133 VGND VGND VPWR VPWR sky130_fd_sc_hd__decap_3
XFILLER_95_656 VGND VGND VPWR VPWR sky130_fd_sc_hd__decap_3
XFILLER_36_701 VGND VGND VPWR VPWR sky130_fd_sc_hd__decap_3
XFILLER_48_561 VGND VGND VPWR VPWR sky130_fd_sc_hd__decap_3
XFILLER_67_369 VGND VGND VPWR VPWR sky130_fd_sc_hd__decap_3
XFILLER_82_306 VGND VGND VPWR VPWR sky130_fd_sc_hd__fill_2
XTAP_TAPCELL_ROW_38_729 VGND VPWR sky130_fd_sc_hd__tapvpwrvgnd_1
XPHY_EDGE_ROW_60_Right_60 VGND VGND VPWR VPWR sky130_fd_sc_hd__decap_3
XFILLER_35_211 VGND VGND VPWR VPWR sky130_fd_sc_hd__fill_1
XFILLER_63_520 VGND VGND VPWR VPWR sky130_fd_sc_hd__decap_3
XFILLER_75_391 VGND VGND VPWR VPWR sky130_fd_sc_hd__fill_1
XFILLER_82_339 VGND VGND VPWR VPWR sky130_fd_sc_hd__fill_1
XFILLER_63_564 VGND VGND VPWR VPWR sky130_fd_sc_hd__fill_2
Xplace520 _6654_/A VGND VGND VPWR VPWR _6650_/A sky130_fd_sc_hd__buf_2
Xplace531 _6678_/A VGND VGND VPWR VPWR _6676_/A sky130_fd_sc_hd__buf_2
X_6820_ clkload5/A _6820_/D VGND VGND VPWR VPWR _6820_/Q sky130_fd_sc_hd__dfxtp_2
XFILLER_50_203 VGND VGND VPWR VPWR sky130_fd_sc_hd__decap_3
XFILLER_90_383 VGND VGND VPWR VPWR sky130_fd_sc_hd__decap_3
Xplace542 _6637_/A VGND VGND VPWR VPWR _6535_/A sky130_fd_sc_hd__buf_2
Xplace553 _6608_/A VGND VGND VPWR VPWR _6570_/A sky130_fd_sc_hd__buf_2
Xplace564 _6626_/A VGND VGND VPWR VPWR _6593_/A sky130_fd_sc_hd__buf_2
XTAP_TAPCELL_ROW_18_486 VGND VPWR sky130_fd_sc_hd__tapvpwrvgnd_1
XPHY_EDGE_ROW_35_Left_155 VGND VGND VPWR VPWR sky130_fd_sc_hd__decap_3
XFILLER_16_480 VGND VGND VPWR VPWR sky130_fd_sc_hd__fill_1
XFILLER_50_236 VGND VGND VPWR VPWR sky130_fd_sc_hd__decap_3
X_6751_ clkload6/A _6751_/D VGND VGND VPWR VPWR _6751_/Q sky130_fd_sc_hd__dfxtp_2
X_6682_ _6683_/A VGND VGND VPWR VPWR _6682_/Y sky130_fd_sc_hd__inv_2
X_3894_ _3728_/Y _3891_/X _3893_/X _3733_/X VGND VGND VPWR VPWR _3894_/X sky130_fd_sc_hd__a22o_2
XFILLER_31_494 VGND VGND VPWR VPWR sky130_fd_sc_hd__fill_2
X_5633_ _5633_/A _5633_/B VGND VGND VPWR VPWR _7012_/D sky130_fd_sc_hd__nor2_2
XFILLER_117_500 VGND VGND VPWR VPWR sky130_fd_sc_hd__decap_3
XFILLER_12_29 VGND VGND VPWR VPWR sky130_fd_sc_hd__decap_3
X_5564_ _5564_/A1 _5647_/A _4751_/B VGND VGND VPWR VPWR _7052_/D sky130_fd_sc_hd__a21bo_2
XFILLER_8_690 VGND VGND VPWR VPWR sky130_fd_sc_hd__decap_3
X_7303_ _7406_/CLK _7303_/D _6583_/Y VGND VGND VPWR VPWR _7303_/Q sky130_fd_sc_hd__dfrtp_2
X_4515_ _4515_/A0 _7290_/Q _4517_/S VGND VGND VPWR VPWR _7322_/D sky130_fd_sc_hd__mux2_2
XFILLER_105_706 VGND VGND VPWR VPWR sky130_fd_sc_hd__decap_3
XFILLER_117_588 VGND VGND VPWR VPWR sky130_fd_sc_hd__decap_3
XPHY_EDGE_ROW_44_Left_164 VGND VGND VPWR VPWR sky130_fd_sc_hd__decap_3
XPHY_EDGE_ROW_103_Right_103 VGND VGND VPWR VPWR sky130_fd_sc_hd__decap_3
XFILLER_104_205 VGND VGND VPWR VPWR sky130_fd_sc_hd__decap_3
XFILLER_104_227 VGND VGND VPWR VPWR sky130_fd_sc_hd__decap_3
X_7234_ _7370_/CLK _7234_/D _6514_/Y VGND VGND VPWR VPWR _7234_/Q sky130_fd_sc_hd__dfrtp_2
X_4446_ _4446_/A _4814_/B VGND VGND VPWR VPWR _4447_/B sky130_fd_sc_hd__nor2_2
X_7165_ _7357_/CLK _7165_/D _6445_/Y VGND VGND VPWR VPWR _7165_/Q sky130_fd_sc_hd__dfrtp_2
X_4377_ _4275_/Y _4375_/X _4376_/X VGND VGND VPWR VPWR _4377_/Y sky130_fd_sc_hd__o21ai_2
XFILLER_100_411 VGND VGND VPWR VPWR sky130_fd_sc_hd__decap_3
XFILLER_98_483 VGND VGND VPWR VPWR sky130_fd_sc_hd__decap_3
X_3328_ _3328_/A _3328_/B VGND VGND VPWR VPWR _3340_/C sky130_fd_sc_hd__nor2_2
XFILLER_112_271 VGND VGND VPWR VPWR sky130_fd_sc_hd__decap_3
XFILLER_85_111 VGND VGND VPWR VPWR sky130_fd_sc_hd__fill_1
XFILLER_85_122 VGND VGND VPWR VPWR sky130_fd_sc_hd__decap_3
XFILLER_86_645 VGND VGND VPWR VPWR sky130_fd_sc_hd__decap_3
X_7096_ _7355_/CLK _7096_/D _6376_/Y VGND VGND VPWR VPWR _7096_/Q sky130_fd_sc_hd__dfrtp_2
XFILLER_100_455 VGND VGND VPWR VPWR sky130_fd_sc_hd__decap_3
XFILLER_100_477 VGND VGND VPWR VPWR sky130_fd_sc_hd__decap_3
XFILLER_27_712 VGND VGND VPWR VPWR sky130_fd_sc_hd__fill_2
XFILLER_39_561 VGND VGND VPWR VPWR sky130_fd_sc_hd__fill_2
XFILLER_85_155 VGND VGND VPWR VPWR sky130_fd_sc_hd__decap_3
XFILLER_86_678 VGND VGND VPWR VPWR sky130_fd_sc_hd__decap_3
XFILLER_26_200 VGND VGND VPWR VPWR sky130_fd_sc_hd__decap_3
XFILLER_26_233 VGND VGND VPWR VPWR sky130_fd_sc_hd__decap_3
XFILLER_26_244 VGND VGND VPWR VPWR sky130_fd_sc_hd__fill_1
XFILLER_42_704 VGND VGND VPWR VPWR sky130_fd_sc_hd__decap_3
XPHY_EDGE_ROW_53_Left_173 VGND VGND VPWR VPWR sky130_fd_sc_hd__decap_3
XFILLER_26_266 VGND VGND VPWR VPWR sky130_fd_sc_hd__decap_3
XFILLER_41_203 VGND VGND VPWR VPWR sky130_fd_sc_hd__fill_1
XFILLER_81_383 VGND VGND VPWR VPWR sky130_fd_sc_hd__decap_3
XFILLER_14_439 VGND VGND VPWR VPWR sky130_fd_sc_hd__decap_3
XFILLER_26_299 VGND VGND VPWR VPWR sky130_fd_sc_hd__decap_3
XFILLER_41_225 VGND VGND VPWR VPWR sky130_fd_sc_hd__decap_3
XFILLER_41_236 VGND VGND VPWR VPWR sky130_fd_sc_hd__decap_3
X_6949_ clkload4/A _6949_/D VGND VGND VPWR VPWR _6949_/Q sky130_fd_sc_hd__dfxtp_2
XFILLER_10_601 VGND VGND VPWR VPWR sky130_fd_sc_hd__decap_3
XFILLER_10_634 VGND VGND VPWR VPWR sky130_fd_sc_hd__decap_3
XFILLER_10_645 VGND VGND VPWR VPWR sky130_fd_sc_hd__decap_3
XFILLER_22_483 VGND VGND VPWR VPWR sky130_fd_sc_hd__decap_3
XFILLER_108_511 VGND VGND VPWR VPWR sky130_fd_sc_hd__decap_3
XFILLER_10_678 VGND VGND VPWR VPWR sky130_fd_sc_hd__decap_3
XFILLER_6_616 VGND VGND VPWR VPWR sky130_fd_sc_hd__decap_3
XFILLER_108_533 VGND VGND VPWR VPWR sky130_fd_sc_hd__decap_3
XFILLER_5_137 VGND VGND VPWR VPWR sky130_fd_sc_hd__decap_3
XTAP_TAPCELL_ROW_118_1731 VGND VPWR sky130_fd_sc_hd__tapvpwrvgnd_1
XPHY_EDGE_ROW_62_Left_182 VGND VGND VPWR VPWR sky130_fd_sc_hd__decap_3
XFILLER_118_62 VGND VGND VPWR VPWR sky130_fd_sc_hd__decap_3
XFILLER_1_310 VGND VGND VPWR VPWR sky130_fd_sc_hd__fill_1
XFILLER_111_709 VGND VGND VPWR VPWR sky130_fd_sc_hd__decap_3
Xhold690 _6744_/Q VGND VGND VPWR VPWR _6744_/D sky130_fd_sc_hd__dlygate4sd3_1
XFILLER_76_100 VGND VGND VPWR VPWR sky130_fd_sc_hd__fill_2
XFILLER_77_623 VGND VGND VPWR VPWR sky130_fd_sc_hd__decap_3
XFILLER_78_77 VGND VGND VPWR VPWR sky130_fd_sc_hd__fill_1
XFILLER_78_88 VGND VGND VPWR VPWR sky130_fd_sc_hd__decap_3
XFILLER_89_461 VGND VGND VPWR VPWR sky130_fd_sc_hd__fill_1
XFILLER_77_656 VGND VGND VPWR VPWR sky130_fd_sc_hd__decap_3
XFILLER_18_701 VGND VGND VPWR VPWR sky130_fd_sc_hd__decap_3
XFILLER_76_144 VGND VGND VPWR VPWR sky130_fd_sc_hd__decap_3
XTAP_TAPCELL_ROW_69_1118 VGND VPWR sky130_fd_sc_hd__tapvpwrvgnd_1
XFILLER_17_200 VGND VGND VPWR VPWR sky130_fd_sc_hd__decap_3
XFILLER_57_380 VGND VGND VPWR VPWR sky130_fd_sc_hd__decap_3
XFILLER_91_136 VGND VGND VPWR VPWR sky130_fd_sc_hd__decap_3
XFILLER_92_637 VGND VGND VPWR VPWR sky130_fd_sc_hd__decap_3
XFILLER_92_648 VGND VGND VPWR VPWR sky130_fd_sc_hd__decap_3
XPHY_EDGE_ROW_71_Left_191 VGND VGND VPWR VPWR sky130_fd_sc_hd__decap_3
XFILLER_45_542 VGND VGND VPWR VPWR sky130_fd_sc_hd__decap_3
XFILLER_91_169 VGND VGND VPWR VPWR sky130_fd_sc_hd__decap_3
XFILLER_72_350 VGND VGND VPWR VPWR sky130_fd_sc_hd__decap_3
XFILLER_72_361 VGND VGND VPWR VPWR sky130_fd_sc_hd__decap_3
XFILLER_60_545 VGND VGND VPWR VPWR sky130_fd_sc_hd__fill_1
XFILLER_72_394 VGND VGND VPWR VPWR sky130_fd_sc_hd__decap_3
XFILLER_13_461 VGND VGND VPWR VPWR sky130_fd_sc_hd__decap_3
XFILLER_20_409 VGND VGND VPWR VPWR sky130_fd_sc_hd__fill_2
XFILLER_60_578 VGND VGND VPWR VPWR sky130_fd_sc_hd__decap_3
XFILLER_60_589 VGND VGND VPWR VPWR sky130_fd_sc_hd__decap_3
XTAP_TAPCELL_ROW_15_445 VGND VPWR sky130_fd_sc_hd__tapvpwrvgnd_1
XFILLER_40_280 VGND VGND VPWR VPWR sky130_fd_sc_hd__decap_3
XTAP_TAPCELL_ROW_43_798 VGND VPWR sky130_fd_sc_hd__tapvpwrvgnd_1
XFILLER_71_6 VGND VGND VPWR VPWR sky130_fd_sc_hd__decap_3
XTAP_TAPCELL_ROW_93_1425 VGND VPWR sky130_fd_sc_hd__tapvpwrvgnd_1
XFILLER_5_671 VGND VGND VPWR VPWR sky130_fd_sc_hd__fill_1
XFILLER_5_682 VGND VGND VPWR VPWR sky130_fd_sc_hd__decap_3
X_5280_ _5280_/A0 _5121_/X _5292_/S VGND VGND VPWR VPWR _7190_/D sky130_fd_sc_hd__mux2_2
X_4300_ _7288_/Q _4300_/B VGND VGND VPWR VPWR _4300_/X sky130_fd_sc_hd__and2_2
XFILLER_99_236 VGND VGND VPWR VPWR sky130_fd_sc_hd__decap_3
XFILLER_114_547 VGND VGND VPWR VPWR sky130_fd_sc_hd__decap_3
XFILLER_87_409 VGND VGND VPWR VPWR sky130_fd_sc_hd__fill_2
X_4231_ _7040_/Q _4244_/B _4354_/B1 _7387_/Q _4230_/X VGND VGND VPWR VPWR _4231_/X
+ sky130_fd_sc_hd__a221o_2
XFILLER_99_269 VGND VGND VPWR VPWR sky130_fd_sc_hd__fill_1
XFILLER_4_85 VGND VGND VPWR VPWR sky130_fd_sc_hd__fill_1
XFILLER_68_612 VGND VGND VPWR VPWR sky130_fd_sc_hd__decap_3
XFILLER_68_645 VGND VGND VPWR VPWR sky130_fd_sc_hd__decap_3
XFILLER_95_420 VGND VGND VPWR VPWR sky130_fd_sc_hd__decap_3
X_4162_ _7137_/Q _4263_/A2 _4161_/X VGND VGND VPWR VPWR _4203_/A sky130_fd_sc_hd__a21o_2
XFILLER_68_678 VGND VGND VPWR VPWR sky130_fd_sc_hd__decap_3
X_4093_ _4394_/A _4394_/B _4092_/X VGND VGND VPWR VPWR _4210_/B sky130_fd_sc_hd__or3b_2
XFILLER_82_103 VGND VGND VPWR VPWR sky130_fd_sc_hd__decap_3
XFILLER_83_626 VGND VGND VPWR VPWR sky130_fd_sc_hd__decap_3
XFILLER_83_659 VGND VGND VPWR VPWR sky130_fd_sc_hd__decap_3
XFILLER_24_704 VGND VGND VPWR VPWR sky130_fd_sc_hd__decap_3
XFILLER_70_309 VGND VGND VPWR VPWR sky130_fd_sc_hd__decap_3
XFILLER_82_136 VGND VGND VPWR VPWR sky130_fd_sc_hd__decap_3
XFILLER_82_147 VGND VGND VPWR VPWR sky130_fd_sc_hd__decap_3
XFILLER_51_523 VGND VGND VPWR VPWR sky130_fd_sc_hd__decap_3
XFILLER_63_361 VGND VGND VPWR VPWR sky130_fd_sc_hd__fill_2
XFILLER_51_556 VGND VGND VPWR VPWR sky130_fd_sc_hd__decap_3
Xplace372 _4327_/A VGND VGND VPWR VPWR _4425_/A sky130_fd_sc_hd__buf_2
Xplace361 _4282_/Y VGND VGND VPWR VPWR _4612_/A sky130_fd_sc_hd__buf_2
Xplace350 _3926_/B1 VGND VGND VPWR VPWR _3759_/A2 sky130_fd_sc_hd__buf_2
X_6803_ _6941_/CLK _6803_/D VGND VGND VPWR VPWR _6803_/Q sky130_fd_sc_hd__dfxtp_2
X_4995_ _4811_/C _4987_/Y _4993_/X _4994_/X VGND VGND VPWR VPWR _5657_/D sky130_fd_sc_hd__a211o_2
XFILLER_51_567 VGND VGND VPWR VPWR sky130_fd_sc_hd__decap_3
Xplace394 _5402_/S VGND VGND VPWR VPWR _5390_/S sky130_fd_sc_hd__buf_2
Xplace383 _5737_/S VGND VGND VPWR VPWR _5735_/S sky130_fd_sc_hd__buf_2
X_6734_ _7189_/CLK _6734_/D VGND VGND VPWR VPWR _6734_/Q sky130_fd_sc_hd__dfxtp_2
XTAP_TAPCELL_ROW_102_1532 VGND VPWR sky130_fd_sc_hd__tapvpwrvgnd_1
X_6665_ _6672_/A VGND VGND VPWR VPWR _6665_/Y sky130_fd_sc_hd__inv_2
X_3877_ _6906_/Q _3892_/A2 _3893_/B1 _6850_/Q _3876_/X VGND VGND VPWR VPWR _3877_/X
+ sky130_fd_sc_hd__a221o_2
X_6596_ _6598_/A VGND VGND VPWR VPWR _6596_/Y sky130_fd_sc_hd__inv_2
XFILLER_2_107 VGND VGND VPWR VPWR sky130_fd_sc_hd__fill_1
XFILLER_105_558 VGND VGND VPWR VPWR sky130_fd_sc_hd__fill_2
X_7217_ _7313_/CLK _7217_/D _6497_/Y VGND VGND VPWR VPWR _7217_/Q sky130_fd_sc_hd__dfrtp_2
X_4429_ _7303_/Q _4488_/S _4437_/B1 _7367_/Q _4429_/C1 VGND VGND VPWR VPWR _4429_/X
+ sky130_fd_sc_hd__a221o_2
XFILLER_59_623 VGND VGND VPWR VPWR sky130_fd_sc_hd__decap_3
XTAP_TAPCELL_ROW_113_1672 VGND VPWR sky130_fd_sc_hd__tapvpwrvgnd_1
XFILLER_113_591 VGND VGND VPWR VPWR sky130_fd_sc_hd__decap_3
XFILLER_58_100 VGND VGND VPWR VPWR sky130_fd_sc_hd__decap_3
XFILLER_58_122 VGND VGND VPWR VPWR sky130_fd_sc_hd__decap_3
XFILLER_59_656 VGND VGND VPWR VPWR sky130_fd_sc_hd__decap_3
XFILLER_86_442 VGND VGND VPWR VPWR sky130_fd_sc_hd__decap_3
X_7148_ _7372_/CLK _7148_/D _6428_/Y VGND VGND VPWR VPWR _7148_/Q sky130_fd_sc_hd__dfrtp_2
XFILLER_58_144 VGND VGND VPWR VPWR sky130_fd_sc_hd__decap_3
XFILLER_74_615 VGND VGND VPWR VPWR sky130_fd_sc_hd__decap_3
XFILLER_86_475 VGND VGND VPWR VPWR sky130_fd_sc_hd__fill_1
X_7079_ _7402_/CLK _7079_/D _6359_/Y VGND VGND VPWR VPWR _7079_/Q sky130_fd_sc_hd__dfrtp_2
XFILLER_100_274 VGND VGND VPWR VPWR sky130_fd_sc_hd__fill_1
XFILLER_74_648 VGND VGND VPWR VPWR sky130_fd_sc_hd__decap_3
XFILLER_100_296 VGND VGND VPWR VPWR sky130_fd_sc_hd__decap_3
XFILLER_39_391 VGND VGND VPWR VPWR sky130_fd_sc_hd__fill_1
XFILLER_64_57 VGND VGND VPWR VPWR sky130_fd_sc_hd__fill_2
XFILLER_73_169 VGND VGND VPWR VPWR sky130_fd_sc_hd__decap_3
XFILLER_82_681 VGND VGND VPWR VPWR sky130_fd_sc_hd__decap_3
XFILLER_27_597 VGND VGND VPWR VPWR sky130_fd_sc_hd__decap_3
XFILLER_30_707 VGND VGND VPWR VPWR sky130_fd_sc_hd__decap_3
XFILLER_42_589 VGND VGND VPWR VPWR sky130_fd_sc_hd__fill_2
XFILLER_80_12 VGND VGND VPWR VPWR sky130_fd_sc_hd__decap_3
XTAP_TAPCELL_ROW_64_1059 VGND VPWR sky130_fd_sc_hd__tapvpwrvgnd_1
Xfanout73 reset VGND VGND VPWR VPWR place571/A sky130_fd_sc_hd__buf_1
XTAP_TAPCELL_ROW_12_404 VGND VPWR sky130_fd_sc_hd__tapvpwrvgnd_1
XFILLER_22_280 VGND VGND VPWR VPWR sky130_fd_sc_hd__decap_3
XFILLER_80_67 VGND VGND VPWR VPWR sky130_fd_sc_hd__decap_3
XTAP_TAPCELL_ROW_40_757 VGND VPWR sky130_fd_sc_hd__tapvpwrvgnd_1
XFILLER_10_475 VGND VGND VPWR VPWR sky130_fd_sc_hd__fill_1
XFILLER_6_413 VGND VGND VPWR VPWR sky130_fd_sc_hd__decap_3
XFILLER_6_435 VGND VGND VPWR VPWR sky130_fd_sc_hd__decap_3
XFILLER_108_352 VGND VGND VPWR VPWR sky130_fd_sc_hd__fill_2
XFILLER_108_374 VGND VGND VPWR VPWR sky130_fd_sc_hd__fill_2
XFILLER_89_76 VGND VGND VPWR VPWR sky130_fd_sc_hd__decap_3
XFILLER_111_517 VGND VGND VPWR VPWR sky130_fd_sc_hd__fill_1
XFILLER_2_663 VGND VGND VPWR VPWR sky130_fd_sc_hd__decap_3
XTAP_TAPCELL_ROW_75_1199 VGND VPWR sky130_fd_sc_hd__tapvpwrvgnd_1
XFILLER_111_539 VGND VGND VPWR VPWR sky130_fd_sc_hd__decap_3
XFILLER_2_696 VGND VGND VPWR VPWR sky130_fd_sc_hd__decap_3
XFILLER_49_111 VGND VGND VPWR VPWR sky130_fd_sc_hd__fill_1
XFILLER_49_122 VGND VGND VPWR VPWR sky130_fd_sc_hd__decap_3
XFILLER_77_420 VGND VGND VPWR VPWR sky130_fd_sc_hd__decap_3
XFILLER_65_615 VGND VGND VPWR VPWR sky130_fd_sc_hd__fill_1
XFILLER_77_464 VGND VGND VPWR VPWR sky130_fd_sc_hd__decap_3
XFILLER_65_626 VGND VGND VPWR VPWR sky130_fd_sc_hd__decap_3
XFILLER_64_147 VGND VGND VPWR VPWR sky130_fd_sc_hd__decap_3
XFILLER_65_659 VGND VGND VPWR VPWR sky130_fd_sc_hd__decap_3
XTAP_TAPCELL_ROW_48_857 VGND VPWR sky130_fd_sc_hd__tapvpwrvgnd_1
XFILLER_18_586 VGND VGND VPWR VPWR sky130_fd_sc_hd__fill_2
XFILLER_33_501 VGND VGND VPWR VPWR sky130_fd_sc_hd__decap_3
XFILLER_52_309 VGND VGND VPWR VPWR sky130_fd_sc_hd__decap_3
XFILLER_80_618 VGND VGND VPWR VPWR sky130_fd_sc_hd__decap_3
XFILLER_92_489 VGND VGND VPWR VPWR sky130_fd_sc_hd__decap_3
XFILLER_72_180 VGND VGND VPWR VPWR sky130_fd_sc_hd__decap_3
X_4780_ _4779_/X _4447_/B _4795_/A VGND VGND VPWR VPWR _4780_/Y sky130_fd_sc_hd__a21oi_2
X_3800_ _6861_/Q _3879_/B1 _3883_/B1 _6901_/Q _3799_/X VGND VGND VPWR VPWR _3800_/X
+ sky130_fd_sc_hd__a221o_2
X_3731_ _6758_/Q _3893_/B1 _3883_/B1 _6770_/Q VGND VGND VPWR VPWR _3731_/X sky130_fd_sc_hd__a22o_2
XFILLER_119_606 VGND VGND VPWR VPWR sky130_fd_sc_hd__fill_2
XFILLER_119_617 VGND VGND VPWR VPWR sky130_fd_sc_hd__decap_3
XFILLER_118_138 VGND VGND VPWR VPWR sky130_fd_sc_hd__fill_2
Xclkload10 _6923_/CLK VGND VGND VPWR VPWR clkload10/Y sky130_fd_sc_hd__clkinvlp_4
X_6450_ _6644_/A VGND VGND VPWR VPWR _6450_/Y sky130_fd_sc_hd__inv_2
XFILLER_9_273 VGND VGND VPWR VPWR sky130_fd_sc_hd__decap_3
Xclkload21 _7388_/CLK VGND VGND VPWR VPWR clkload21/Y sky130_fd_sc_hd__inv_6
Xclkload32 _7358_/CLK VGND VGND VPWR VPWR clkload32/X sky130_fd_sc_hd__clkbuf_8
X_6381_ _6570_/A VGND VGND VPWR VPWR _6381_/Y sky130_fd_sc_hd__inv_2
X_3593_ _3620_/A _4292_/B _3592_/X VGND VGND VPWR VPWR _3594_/B sky130_fd_sc_hd__a21o_2
XFILLER_88_707 VGND VGND VPWR VPWR sky130_fd_sc_hd__decap_3
XFILLER_102_528 VGND VGND VPWR VPWR sky130_fd_sc_hd__decap_3
XFILLER_114_388 VGND VGND VPWR VPWR sky130_fd_sc_hd__decap_3
XFILLER_87_217 VGND VGND VPWR VPWR sky130_fd_sc_hd__decap_3
XFILLER_87_228 VGND VGND VPWR VPWR sky130_fd_sc_hd__decap_3
X_7002_ _7373_/CLK _7002_/D _6282_/Y VGND VGND VPWR VPWR _7002_/Q sky130_fd_sc_hd__dfrtp_2
X_5194_ _5194_/A _5207_/B VGND VGND VPWR VPWR _7231_/D sky130_fd_sc_hd__and2_2
X_4214_ _7228_/Q _4421_/A2 _3366_/X _7164_/Q _4213_/X VGND VGND VPWR VPWR _4214_/X
+ sky130_fd_sc_hd__a221o_2
XFILLER_68_442 VGND VGND VPWR VPWR sky130_fd_sc_hd__decap_3
X_4145_ _7298_/Q _4419_/A2 _4144_/X _4248_/A VGND VGND VPWR VPWR _4145_/X sky130_fd_sc_hd__a211o_2
XFILLER_56_637 VGND VGND VPWR VPWR sky130_fd_sc_hd__decap_3
XFILLER_56_648 VGND VGND VPWR VPWR sky130_fd_sc_hd__decap_3
XFILLER_55_136 VGND VGND VPWR VPWR sky130_fd_sc_hd__decap_3
XFILLER_71_607 VGND VGND VPWR VPWR sky130_fd_sc_hd__decap_3
X_4076_ _7147_/Q _4434_/B1 _4436_/B1 _7179_/Q VGND VGND VPWR VPWR _4076_/X sky130_fd_sc_hd__a22o_2
XFILLER_24_501 VGND VGND VPWR VPWR sky130_fd_sc_hd__decap_3
XFILLER_55_169 VGND VGND VPWR VPWR sky130_fd_sc_hd__decap_3
XFILLER_64_681 VGND VGND VPWR VPWR sky130_fd_sc_hd__decap_3
XFILLER_70_106 VGND VGND VPWR VPWR sky130_fd_sc_hd__decap_3
XFILLER_71_629 VGND VGND VPWR VPWR sky130_fd_sc_hd__decap_3
XFILLER_34_27 VGND VGND VPWR VPWR sky130_fd_sc_hd__fill_1
XFILLER_70_139 VGND VGND VPWR VPWR sky130_fd_sc_hd__fill_1
XFILLER_12_707 VGND VGND VPWR VPWR sky130_fd_sc_hd__decap_3
XFILLER_34_38 VGND VGND VPWR VPWR sky130_fd_sc_hd__decap_3
XFILLER_11_239 VGND VGND VPWR VPWR sky130_fd_sc_hd__decap_3
XFILLER_24_589 VGND VGND VPWR VPWR sky130_fd_sc_hd__decap_3
X_4978_ _4910_/A _4973_/X _4975_/Y _6993_/D _4606_/A VGND VGND VPWR VPWR _4978_/X
+ sky130_fd_sc_hd__a32o_2
Xclkload4 clkload4/A VGND VGND VPWR VPWR clkload4/Y sky130_fd_sc_hd__clkinv_2
X_6717_ _6941_/CLK _6717_/D VGND VGND VPWR VPWR _6717_/Q sky130_fd_sc_hd__dfxtp_2
XFILLER_109_116 VGND VGND VPWR VPWR sky130_fd_sc_hd__decap_3
X_6648_ _6648_/A VGND VGND VPWR VPWR _6648_/Y sky130_fd_sc_hd__inv_2
XFILLER_109_149 VGND VGND VPWR VPWR sky130_fd_sc_hd__decap_3
XFILLER_119_6 VGND VGND VPWR VPWR sky130_fd_sc_hd__fill_1
XTAP_TAPCELL_ROW_115_1701 VGND VPWR sky130_fd_sc_hd__tapvpwrvgnd_1
XFILLER_118_672 VGND VGND VPWR VPWR sky130_fd_sc_hd__decap_3
XFILLER_3_405 VGND VGND VPWR VPWR sky130_fd_sc_hd__decap_3
X_6579_ _6584_/A VGND VGND VPWR VPWR _6579_/Y sky130_fd_sc_hd__inv_2
XFILLER_105_322 VGND VGND VPWR VPWR sky130_fd_sc_hd__decap_3
XFILLER_3_449 VGND VGND VPWR VPWR sky130_fd_sc_hd__decap_3
XFILLER_105_355 VGND VGND VPWR VPWR sky130_fd_sc_hd__decap_3
Xoutput581 _5657_/C VGND VGND VPWR VPWR alu_result_out[18] sky130_fd_sc_hd__clkdlybuf4s25_1
XFILLER_115_30 VGND VGND VPWR VPWR sky130_fd_sc_hd__decap_3
XFILLER_59_420 VGND VGND VPWR VPWR sky130_fd_sc_hd__fill_1
Xoutput592 _5663_/A VGND VGND VPWR VPWR alu_result_out[28] sky130_fd_sc_hd__clkdlybuf4s25_1
XFILLER_115_63 VGND VGND VPWR VPWR sky130_fd_sc_hd__decap_3
XFILLER_47_604 VGND VGND VPWR VPWR sky130_fd_sc_hd__decap_3
XFILLER_86_250 VGND VGND VPWR VPWR sky130_fd_sc_hd__fill_2
XFILLER_101_572 VGND VGND VPWR VPWR sky130_fd_sc_hd__fill_2
XFILLER_101_583 VGND VGND VPWR VPWR sky130_fd_sc_hd__decap_3
XFILLER_115_96 VGND VGND VPWR VPWR sky130_fd_sc_hd__decap_3
XFILLER_47_626 VGND VGND VPWR VPWR sky130_fd_sc_hd__decap_3
XFILLER_46_136 VGND VGND VPWR VPWR sky130_fd_sc_hd__decap_3
XFILLER_47_659 VGND VGND VPWR VPWR sky130_fd_sc_hd__decap_3
XFILLER_86_294 VGND VGND VPWR VPWR sky130_fd_sc_hd__decap_3
XFILLER_62_629 VGND VGND VPWR VPWR sky130_fd_sc_hd__decap_3
XTAP_TAPCELL_ROW_45_816 VGND VPWR sky130_fd_sc_hd__tapvpwrvgnd_1
XFILLER_15_534 VGND VGND VPWR VPWR sky130_fd_sc_hd__fill_1
XFILLER_54_180 VGND VGND VPWR VPWR sky130_fd_sc_hd__decap_3
XFILLER_61_128 VGND VGND VPWR VPWR sky130_fd_sc_hd__decap_3
XFILLER_70_640 VGND VGND VPWR VPWR sky130_fd_sc_hd__decap_3
XFILLER_91_11 VGND VGND VPWR VPWR sky130_fd_sc_hd__fill_1
XFILLER_15_556 VGND VGND VPWR VPWR sky130_fd_sc_hd__fill_1
XFILLER_15_578 VGND VGND VPWR VPWR sky130_fd_sc_hd__decap_3
XFILLER_70_651 VGND VGND VPWR VPWR sky130_fd_sc_hd__decap_3
XFILLER_42_397 VGND VGND VPWR VPWR sky130_fd_sc_hd__fill_2
XFILLER_70_684 VGND VGND VPWR VPWR sky130_fd_sc_hd__decap_3
XFILLER_91_77 VGND VGND VPWR VPWR sky130_fd_sc_hd__decap_3
XTAP_TAPCELL_ROW_25_573 VGND VPWR sky130_fd_sc_hd__tapvpwrvgnd_1
XFILLER_7_700 VGND VGND VPWR VPWR sky130_fd_sc_hd__decap_3
XFILLER_10_261 VGND VGND VPWR VPWR sky130_fd_sc_hd__fill_2
XFILLER_109_650 VGND VGND VPWR VPWR sky130_fd_sc_hd__decap_3
XTAP_TAPCELL_ROW_77_1217 VGND VPWR sky130_fd_sc_hd__tapvpwrvgnd_1
XFILLER_109_694 VGND VGND VPWR VPWR sky130_fd_sc_hd__decap_3
XFILLER_40_81 VGND VGND VPWR VPWR sky130_fd_sc_hd__decap_3
XFILLER_6_276 VGND VGND VPWR VPWR sky130_fd_sc_hd__decap_3
XFILLER_108_193 VGND VGND VPWR VPWR sky130_fd_sc_hd__decap_3
XFILLER_69_217 VGND VGND VPWR VPWR sky130_fd_sc_hd__decap_3
XFILLER_111_314 VGND VGND VPWR VPWR sky130_fd_sc_hd__decap_3
XFILLER_69_228 VGND VGND VPWR VPWR sky130_fd_sc_hd__decap_3
XFILLER_69_239 VGND VGND VPWR VPWR sky130_fd_sc_hd__decap_3
XFILLER_97_559 VGND VGND VPWR VPWR sky130_fd_sc_hd__fill_1
XFILLER_38_604 VGND VGND VPWR VPWR sky130_fd_sc_hd__decap_3
XFILLER_84_209 VGND VGND VPWR VPWR sky130_fd_sc_hd__decap_3
XFILLER_1_20 VGND VGND VPWR VPWR sky130_fd_sc_hd__fill_2
XFILLER_38_637 VGND VGND VPWR VPWR sky130_fd_sc_hd__decap_3
XFILLER_38_648 VGND VGND VPWR VPWR sky130_fd_sc_hd__decap_3
XTAP_TAPCELL_ROW_88_1357 VGND VPWR sky130_fd_sc_hd__tapvpwrvgnd_1
XFILLER_53_629 VGND VGND VPWR VPWR sky130_fd_sc_hd__decap_3
XFILLER_80_404 VGND VGND VPWR VPWR sky130_fd_sc_hd__fill_1
XPHY_EDGE_ROW_9_Left_129 VGND VGND VPWR VPWR sky130_fd_sc_hd__decap_3
XFILLER_33_320 VGND VGND VPWR VPWR sky130_fd_sc_hd__decap_3
XFILLER_45_180 VGND VGND VPWR VPWR sky130_fd_sc_hd__decap_3
XFILLER_46_681 VGND VGND VPWR VPWR sky130_fd_sc_hd__decap_3
XFILLER_80_448 VGND VGND VPWR VPWR sky130_fd_sc_hd__decap_3
X_4901_ _4901_/A0 _4899_/X _4979_/S VGND VGND VPWR VPWR _7268_/D sky130_fd_sc_hd__mux2_2
XFILLER_61_662 VGND VGND VPWR VPWR sky130_fd_sc_hd__decap_3
XFILLER_61_673 VGND VGND VPWR VPWR sky130_fd_sc_hd__decap_3
XFILLER_60_150 VGND VGND VPWR VPWR sky130_fd_sc_hd__decap_3
XFILLER_60_161 VGND VGND VPWR VPWR sky130_fd_sc_hd__decap_3
XFILLER_60_183 VGND VGND VPWR VPWR sky130_fd_sc_hd__decap_3
X_4832_ _4832_/A _5657_/A VGND VGND VPWR VPWR _4832_/X sky130_fd_sc_hd__or2_2
XFILLER_21_559 VGND VGND VPWR VPWR sky130_fd_sc_hd__fill_1
X_4763_ _4762_/A _4762_/B _3548_/X VGND VGND VPWR VPWR _4763_/X sky130_fd_sc_hd__a21o_2
XFILLER_119_414 VGND VGND VPWR VPWR sky130_fd_sc_hd__decap_3
X_6502_ _6563_/A VGND VGND VPWR VPWR _6502_/Y sky130_fd_sc_hd__inv_2
X_4694_ _7008_/Q _4728_/A VGND VGND VPWR VPWR _4694_/Y sky130_fd_sc_hd__nor2_2
X_3714_ _3735_/A _3741_/B _3746_/C VGND VGND VPWR VPWR _3714_/X sky130_fd_sc_hd__and3_2
XFILLER_119_458 VGND VGND VPWR VPWR sky130_fd_sc_hd__decap_3
X_6433_ _6626_/A VGND VGND VPWR VPWR _6433_/Y sky130_fd_sc_hd__inv_2
XFILLER_106_119 VGND VGND VPWR VPWR sky130_fd_sc_hd__decap_3
XFILLER_20_29 VGND VGND VPWR VPWR sky130_fd_sc_hd__decap_3
X_3645_ _3645_/A1 _3857_/A2 _4664_/B VGND VGND VPWR VPWR _7406_/D sky130_fd_sc_hd__a21o_2
XTAP_TAPCELL_ROW_99_1497 VGND VPWR sky130_fd_sc_hd__tapvpwrvgnd_1
XFILLER_115_620 VGND VGND VPWR VPWR sky130_fd_sc_hd__decap_3
XFILLER_115_653 VGND VGND VPWR VPWR sky130_fd_sc_hd__decap_3
X_6364_ _6649_/A VGND VGND VPWR VPWR _6364_/Y sky130_fd_sc_hd__inv_2
X_3576_ _7252_/Q _4599_/S _3377_/X _7220_/Q _3575_/X VGND VGND VPWR VPWR _3576_/Y
+ sky130_fd_sc_hd__a221oi_2
XFILLER_0_408 VGND VGND VPWR VPWR sky130_fd_sc_hd__decap_3
XFILLER_114_141 VGND VGND VPWR VPWR sky130_fd_sc_hd__decap_3
XFILLER_88_504 VGND VGND VPWR VPWR sky130_fd_sc_hd__decap_3
XFILLER_88_515 VGND VGND VPWR VPWR sky130_fd_sc_hd__decap_3
X_6295_ _6535_/A VGND VGND VPWR VPWR _6295_/Y sky130_fd_sc_hd__inv_2
X_5315_ _5315_/A0 _4878_/X _5315_/S VGND VGND VPWR VPWR _7173_/D sky130_fd_sc_hd__mux2_2
XFILLER_115_697 VGND VGND VPWR VPWR sky130_fd_sc_hd__decap_3
XTAP_TAPCELL_ROW_110_1631 VGND VPWR sky130_fd_sc_hd__tapvpwrvgnd_1
XPHY_EDGE_ROW_89_Right_89 VGND VGND VPWR VPWR sky130_fd_sc_hd__decap_3
XFILLER_29_615 VGND VGND VPWR VPWR sky130_fd_sc_hd__fill_1
XFILLER_29_626 VGND VGND VPWR VPWR sky130_fd_sc_hd__decap_3
XFILLER_56_401 VGND VGND VPWR VPWR sky130_fd_sc_hd__decap_3
XFILLER_68_250 VGND VGND VPWR VPWR sky130_fd_sc_hd__fill_2
XFILLER_84_710 VGND VGND VPWR VPWR sky130_fd_sc_hd__decap_3
X_5177_ _5177_/A _5198_/B VGND VGND VPWR VPWR _7239_/D sky130_fd_sc_hd__and2_2
XFILLER_110_380 VGND VGND VPWR VPWR sky130_fd_sc_hd__decap_3
XFILLER_28_147 VGND VGND VPWR VPWR sky130_fd_sc_hd__decap_3
XFILLER_29_659 VGND VGND VPWR VPWR sky130_fd_sc_hd__decap_3
XFILLER_68_294 VGND VGND VPWR VPWR sky130_fd_sc_hd__decap_3
XFILLER_83_220 VGND VGND VPWR VPWR sky130_fd_sc_hd__decap_3
XFILLER_83_231 VGND VGND VPWR VPWR sky130_fd_sc_hd__decap_3
X_4128_ _7331_/Q _3954_/S _4428_/B1 _7139_/Q VGND VGND VPWR VPWR _4128_/X sky130_fd_sc_hd__a22o_2
XFILLER_44_607 VGND VGND VPWR VPWR sky130_fd_sc_hd__decap_3
XFILLER_71_415 VGND VGND VPWR VPWR sky130_fd_sc_hd__fill_2
X_4059_ _7276_/Q _4131_/A2 _4056_/X _4058_/X VGND VGND VPWR VPWR _4059_/X sky130_fd_sc_hd__a211o_2
XFILLER_71_426 VGND VGND VPWR VPWR sky130_fd_sc_hd__fill_2
XFILLER_71_437 VGND VGND VPWR VPWR sky130_fd_sc_hd__fill_1
XFILLER_83_297 VGND VGND VPWR VPWR sky130_fd_sc_hd__decap_3
XFILLER_52_640 VGND VGND VPWR VPWR sky130_fd_sc_hd__decap_3
XFILLER_52_651 VGND VGND VPWR VPWR sky130_fd_sc_hd__decap_3
XFILLER_101_65 VGND VGND VPWR VPWR sky130_fd_sc_hd__decap_3
XFILLER_24_386 VGND VGND VPWR VPWR sky130_fd_sc_hd__decap_3
XFILLER_51_161 VGND VGND VPWR VPWR sky130_fd_sc_hd__decap_3
XFILLER_51_172 VGND VGND VPWR VPWR sky130_fd_sc_hd__decap_3
XFILLER_52_684 VGND VGND VPWR VPWR sky130_fd_sc_hd__decap_3
XTAP_TAPCELL_ROW_61_1018 VGND VPWR sky130_fd_sc_hd__tapvpwrvgnd_1
XPHY_EDGE_ROW_98_Right_98 VGND VGND VPWR VPWR sky130_fd_sc_hd__decap_3
XFILLER_101_87 VGND VGND VPWR VPWR sky130_fd_sc_hd__decap_3
XFILLER_8_519 VGND VGND VPWR VPWR sky130_fd_sc_hd__decap_3
XTAP_TAPCELL_ROW_22_532 VGND VPWR sky130_fd_sc_hd__tapvpwrvgnd_1
XTAP_TAPCELL_ROW_50_885 VGND VPWR sky130_fd_sc_hd__tapvpwrvgnd_1
XFILLER_20_592 VGND VGND VPWR VPWR sky130_fd_sc_hd__decap_3
XFILLER_3_202 VGND VGND VPWR VPWR sky130_fd_sc_hd__decap_3
XFILLER_106_631 VGND VGND VPWR VPWR sky130_fd_sc_hd__decap_3
XFILLER_105_141 VGND VGND VPWR VPWR sky130_fd_sc_hd__decap_3
XFILLER_106_675 VGND VGND VPWR VPWR sky130_fd_sc_hd__decap_3
XFILLER_3_246 VGND VGND VPWR VPWR sky130_fd_sc_hd__decap_3
XFILLER_3_279 VGND VGND VPWR VPWR sky130_fd_sc_hd__fill_1
XFILLER_79_548 VGND VGND VPWR VPWR sky130_fd_sc_hd__decap_3
XTAP_TAPCELL_ROW_72_1158 VGND VPWR sky130_fd_sc_hd__tapvpwrvgnd_1
XFILLER_66_209 VGND VGND VPWR VPWR sky130_fd_sc_hd__decap_3
XFILLER_86_55 VGND VGND VPWR VPWR sky130_fd_sc_hd__decap_3
XFILLER_59_272 VGND VGND VPWR VPWR sky130_fd_sc_hd__decap_3
XFILLER_86_88 VGND VGND VPWR VPWR sky130_fd_sc_hd__decap_3
XFILLER_101_380 VGND VGND VPWR VPWR sky130_fd_sc_hd__fill_1
XFILLER_19_147 VGND VGND VPWR VPWR sky130_fd_sc_hd__decap_3
XFILLER_59_294 VGND VGND VPWR VPWR sky130_fd_sc_hd__fill_2
XFILLER_74_231 VGND VGND VPWR VPWR sky130_fd_sc_hd__decap_3
XFILLER_19_169 VGND VGND VPWR VPWR sky130_fd_sc_hd__fill_1
XFILLER_35_629 VGND VGND VPWR VPWR sky130_fd_sc_hd__decap_3
XFILLER_62_404 VGND VGND VPWR VPWR sky130_fd_sc_hd__decap_3
XFILLER_62_415 VGND VGND VPWR VPWR sky130_fd_sc_hd__decap_3
XFILLER_74_253 VGND VGND VPWR VPWR sky130_fd_sc_hd__decap_3
XFILLER_90_713 VGND VGND VPWR VPWR sky130_fd_sc_hd__fill_1
XTAP_TAPCELL_ROW_58_985 VGND VPWR sky130_fd_sc_hd__tapvpwrvgnd_1
XFILLER_28_681 VGND VGND VPWR VPWR sky130_fd_sc_hd__decap_3
XFILLER_34_139 VGND VGND VPWR VPWR sky130_fd_sc_hd__fill_1
XFILLER_62_448 VGND VGND VPWR VPWR sky130_fd_sc_hd__decap_3
XFILLER_15_353 VGND VGND VPWR VPWR sky130_fd_sc_hd__decap_3
XFILLER_43_662 VGND VGND VPWR VPWR sky130_fd_sc_hd__decap_3
XFILLER_30_301 VGND VGND VPWR VPWR sky130_fd_sc_hd__decap_3
XFILLER_42_161 VGND VGND VPWR VPWR sky130_fd_sc_hd__decap_3
XFILLER_42_172 VGND VGND VPWR VPWR sky130_fd_sc_hd__decap_3
XFILLER_43_673 VGND VGND VPWR VPWR sky130_fd_sc_hd__decap_3
XFILLER_30_345 VGND VGND VPWR VPWR sky130_fd_sc_hd__decap_3
XTAP_TAPCELL_ROW_83_1298 VGND VPWR sky130_fd_sc_hd__tapvpwrvgnd_1
XFILLER_11_570 VGND VGND VPWR VPWR sky130_fd_sc_hd__decap_3
XFILLER_116_406 VGND VGND VPWR VPWR sky130_fd_sc_hd__decap_3
XFILLER_7_585 VGND VGND VPWR VPWR sky130_fd_sc_hd__decap_3
XFILLER_112_601 VGND VGND VPWR VPWR sky130_fd_sc_hd__decap_3
X_3361_ _5129_/A _3386_/B VGND VGND VPWR VPWR _3376_/B sky130_fd_sc_hd__and2_2
XFILLER_112_634 VGND VGND VPWR VPWR sky130_fd_sc_hd__decap_3
XFILLER_32_3 VGND VGND VPWR VPWR sky130_fd_sc_hd__fill_1
X_5100_ _5100_/A _5100_/B VGND VGND VPWR VPWR _5100_/Y sky130_fd_sc_hd__xnor2_2
XFILLER_111_133 VGND VGND VPWR VPWR sky130_fd_sc_hd__fill_2
XFILLER_112_645 VGND VGND VPWR VPWR sky130_fd_sc_hd__decap_3
XFILLER_112_678 VGND VGND VPWR VPWR sky130_fd_sc_hd__decap_3
X_5031_ _5032_/A _5031_/B VGND VGND VPWR VPWR _5031_/X sky130_fd_sc_hd__xor2_2
XFILLER_111_188 VGND VGND VPWR VPWR sky130_fd_sc_hd__decap_3
XFILLER_57_209 VGND VGND VPWR VPWR sky130_fd_sc_hd__decap_3
XFILLER_66_710 VGND VGND VPWR VPWR sky130_fd_sc_hd__decap_3
XFILLER_78_581 VGND VGND VPWR VPWR sky130_fd_sc_hd__decap_3
Xhold1208 _7126_/Q VGND VGND VPWR VPWR _5415_/A0 sky130_fd_sc_hd__dlygate4sd3_1
Xhold1219 _7180_/Q VGND VGND VPWR VPWR _5300_/A0 sky130_fd_sc_hd__dlygate4sd3_1
XFILLER_65_220 VGND VGND VPWR VPWR sky130_fd_sc_hd__decap_3
XFILLER_26_607 VGND VGND VPWR VPWR sky130_fd_sc_hd__decap_3
XFILLER_65_275 VGND VGND VPWR VPWR sky130_fd_sc_hd__decap_3
XFILLER_25_128 VGND VGND VPWR VPWR sky130_fd_sc_hd__decap_3
XFILLER_53_426 VGND VGND VPWR VPWR sky130_fd_sc_hd__fill_2
XFILLER_65_297 VGND VGND VPWR VPWR sky130_fd_sc_hd__fill_2
XFILLER_80_234 VGND VGND VPWR VPWR sky130_fd_sc_hd__decap_3
X_6982_ _7349_/CLK _6982_/D _6262_/Y VGND VGND VPWR VPWR _6982_/Q sky130_fd_sc_hd__dfrtp_2
XTAP_TAPCELL_ROW_0_249 VGND VPWR sky130_fd_sc_hd__tapvpwrvgnd_1
XFILLER_34_640 VGND VGND VPWR VPWR sky130_fd_sc_hd__decap_3
XFILLER_34_651 VGND VGND VPWR VPWR sky130_fd_sc_hd__decap_3
XFILLER_80_256 VGND VGND VPWR VPWR sky130_fd_sc_hd__fill_2
XFILLER_80_267 VGND VGND VPWR VPWR sky130_fd_sc_hd__decap_3
XFILLER_33_172 VGND VGND VPWR VPWR sky130_fd_sc_hd__decap_3
XFILLER_34_684 VGND VGND VPWR VPWR sky130_fd_sc_hd__decap_3
XFILLER_21_323 VGND VGND VPWR VPWR sky130_fd_sc_hd__decap_3
X_4815_ _4812_/Y _4813_/Y _4814_/Y _4779_/X VGND VGND VPWR VPWR _4815_/X sky130_fd_sc_hd__o211a_2
XFILLER_119_200 VGND VGND VPWR VPWR sky130_fd_sc_hd__fill_2
XFILLER_119_222 VGND VGND VPWR VPWR sky130_fd_sc_hd__fill_2
XFILLER_31_28 VGND VGND VPWR VPWR sky130_fd_sc_hd__fill_1
X_4746_ _4764_/B _4069_/B _4744_/Y _4745_/Y _4852_/A VGND VGND VPWR VPWR _4746_/X
+ sky130_fd_sc_hd__o32a_2
X_4677_ _6989_/Q _4677_/B VGND VGND VPWR VPWR _5036_/A sky130_fd_sc_hd__and2_2
XFILLER_103_9 VGND VGND VPWR VPWR sky130_fd_sc_hd__decap_3
XFILLER_107_439 VGND VGND VPWR VPWR sky130_fd_sc_hd__decap_3
X_7396_ _7396_/CLK _7396_/D _6676_/Y VGND VGND VPWR VPWR _7396_/Q sky130_fd_sc_hd__dfrtp_2
X_6416_ _6644_/A VGND VGND VPWR VPWR _6416_/Y sky130_fd_sc_hd__inv_2
XFILLER_1_706 VGND VGND VPWR VPWR sky130_fd_sc_hd__decap_3
X_6347_ _6667_/A VGND VGND VPWR VPWR _6347_/Y sky130_fd_sc_hd__inv_2
XFILLER_0_216 VGND VGND VPWR VPWR sky130_fd_sc_hd__decap_3
XFILLER_102_100 VGND VGND VPWR VPWR sky130_fd_sc_hd__decap_3
XFILLER_103_612 VGND VGND VPWR VPWR sky130_fd_sc_hd__decap_3
XFILLER_103_623 VGND VGND VPWR VPWR sky130_fd_sc_hd__decap_3
XFILLER_115_494 VGND VGND VPWR VPWR sky130_fd_sc_hd__decap_3
XFILLER_88_301 VGND VGND VPWR VPWR sky130_fd_sc_hd__decap_3
XFILLER_88_312 VGND VGND VPWR VPWR sky130_fd_sc_hd__decap_3
XFILLER_88_323 VGND VGND VPWR VPWR sky130_fd_sc_hd__decap_3
X_3559_ _3553_/X _3557_/X _3558_/X _3590_/A VGND VGND VPWR VPWR _4295_/B sky130_fd_sc_hd__o211a_2
XFILLER_0_249 VGND VGND VPWR VPWR sky130_fd_sc_hd__decap_3
XFILLER_102_133 VGND VGND VPWR VPWR sky130_fd_sc_hd__decap_3
XFILLER_103_656 VGND VGND VPWR VPWR sky130_fd_sc_hd__decap_3
X_6278_ _6288_/A VGND VGND VPWR VPWR _6278_/Y sky130_fd_sc_hd__inv_2
XFILLER_102_177 VGND VGND VPWR VPWR sky130_fd_sc_hd__decap_3
XFILLER_88_389 VGND VGND VPWR VPWR sky130_fd_sc_hd__decap_3
X_5229_ _5362_/C _5229_/B _5229_/C VGND VGND VPWR VPWR _5292_/S sky130_fd_sc_hd__and3b_2
XFILLER_29_423 VGND VGND VPWR VPWR sky130_fd_sc_hd__decap_3
XFILLER_56_25 VGND VGND VPWR VPWR sky130_fd_sc_hd__decap_3
XFILLER_17_629 VGND VGND VPWR VPWR sky130_fd_sc_hd__decap_3
XFILLER_56_253 VGND VGND VPWR VPWR sky130_fd_sc_hd__fill_1
XFILLER_72_713 VGND VGND VPWR VPWR sky130_fd_sc_hd__fill_1
XFILLER_44_448 VGND VGND VPWR VPWR sky130_fd_sc_hd__decap_3
XFILLER_56_275 VGND VGND VPWR VPWR sky130_fd_sc_hd__decap_3
XFILLER_71_223 VGND VGND VPWR VPWR sky130_fd_sc_hd__fill_1
XTAP_TAPCELL_ROW_55_944 VGND VPWR sky130_fd_sc_hd__tapvpwrvgnd_1
XFILLER_112_53 VGND VGND VPWR VPWR sky130_fd_sc_hd__decap_3
XFILLER_25_662 VGND VGND VPWR VPWR sky130_fd_sc_hd__decap_3
XFILLER_71_245 VGND VGND VPWR VPWR sky130_fd_sc_hd__decap_3
XFILLER_24_150 VGND VGND VPWR VPWR sky130_fd_sc_hd__decap_3
XFILLER_25_673 VGND VGND VPWR VPWR sky130_fd_sc_hd__decap_3
XFILLER_40_610 VGND VGND VPWR VPWR sky130_fd_sc_hd__decap_3
XFILLER_72_35 VGND VGND VPWR VPWR sky130_fd_sc_hd__decap_3
XFILLER_12_345 VGND VGND VPWR VPWR sky130_fd_sc_hd__decap_3
XFILLER_24_183 VGND VGND VPWR VPWR sky130_fd_sc_hd__decap_3
XFILLER_40_643 VGND VGND VPWR VPWR sky130_fd_sc_hd__fill_1
XFILLER_40_654 VGND VGND VPWR VPWR sky130_fd_sc_hd__decap_3
XFILLER_52_492 VGND VGND VPWR VPWR sky130_fd_sc_hd__decap_3
XTAP_TAPCELL_ROW_35_690 VGND VPWR sky130_fd_sc_hd__tapvpwrvgnd_1
XFILLER_40_687 VGND VGND VPWR VPWR sky130_fd_sc_hd__decap_3
XFILLER_8_305 VGND VGND VPWR VPWR sky130_fd_sc_hd__decap_3
XPHY_EDGE_ROW_117_Right_117 VGND VGND VPWR VPWR sky130_fd_sc_hd__decap_3
XFILLER_8_349 VGND VGND VPWR VPWR sky130_fd_sc_hd__decap_3
XFILLER_21_72 VGND VGND VPWR VPWR sky130_fd_sc_hd__decap_3
XFILLER_4_533 VGND VGND VPWR VPWR sky130_fd_sc_hd__decap_3
XFILLER_4_566 VGND VGND VPWR VPWR sky130_fd_sc_hd__decap_3
XFILLER_4_599 VGND VGND VPWR VPWR sky130_fd_sc_hd__decap_3
XFILLER_97_54 VGND VGND VPWR VPWR sky130_fd_sc_hd__fill_2
XFILLER_48_710 VGND VGND VPWR VPWR sky130_fd_sc_hd__decap_3
XFILLER_67_529 VGND VGND VPWR VPWR sky130_fd_sc_hd__fill_2
XFILLER_94_315 VGND VGND VPWR VPWR sky130_fd_sc_hd__fill_2
XFILLER_47_220 VGND VGND VPWR VPWR sky130_fd_sc_hd__decap_3
XFILLER_47_231 VGND VGND VPWR VPWR sky130_fd_sc_hd__decap_3
XFILLER_35_426 VGND VGND VPWR VPWR sky130_fd_sc_hd__fill_1
XFILLER_75_595 VGND VGND VPWR VPWR sky130_fd_sc_hd__decap_3
XTAP_TAPCELL_ROW_85_1316 VGND VPWR sky130_fd_sc_hd__tapvpwrvgnd_1
XFILLER_16_640 VGND VGND VPWR VPWR sky130_fd_sc_hd__decap_3
XFILLER_16_651 VGND VGND VPWR VPWR sky130_fd_sc_hd__decap_3
XFILLER_35_459 VGND VGND VPWR VPWR sky130_fd_sc_hd__fill_1
XFILLER_16_684 VGND VGND VPWR VPWR sky130_fd_sc_hd__decap_3
XFILLER_31_610 VGND VGND VPWR VPWR sky130_fd_sc_hd__decap_3
XFILLER_43_470 VGND VGND VPWR VPWR sky130_fd_sc_hd__decap_3
XFILLER_62_278 VGND VGND VPWR VPWR sky130_fd_sc_hd__decap_3
XFILLER_31_632 VGND VGND VPWR VPWR sky130_fd_sc_hd__decap_3
XPHY_EDGE_ROW_99_Left_219 VGND VGND VPWR VPWR sky130_fd_sc_hd__decap_3
XFILLER_31_665 VGND VGND VPWR VPWR sky130_fd_sc_hd__decap_3
XFILLER_31_676 VGND VGND VPWR VPWR sky130_fd_sc_hd__decap_3
XFILLER_30_197 VGND VGND VPWR VPWR sky130_fd_sc_hd__decap_3
XFILLER_7_360 VGND VGND VPWR VPWR sky130_fd_sc_hd__decap_3
XFILLER_7_393 VGND VGND VPWR VPWR sky130_fd_sc_hd__decap_3
X_7250_ _7313_/CLK _7250_/D _6530_/Y VGND VGND VPWR VPWR _7250_/Q sky130_fd_sc_hd__dfrtp_2
X_4462_ _3621_/B _3618_/X _3541_/X VGND VGND VPWR VPWR _4462_/Y sky130_fd_sc_hd__o21ai_2
XTAP_TAPCELL_ROW_96_1456 VGND VPWR sky130_fd_sc_hd__tapvpwrvgnd_1
XFILLER_116_247 VGND VGND VPWR VPWR sky130_fd_sc_hd__decap_3
XFILLER_89_109 VGND VGND VPWR VPWR sky130_fd_sc_hd__decap_3
X_3413_ _7155_/Q _4352_/B1 _3410_/X _3412_/X VGND VGND VPWR VPWR _3413_/X sky130_fd_sc_hd__a211o_2
XFILLER_98_621 VGND VGND VPWR VPWR sky130_fd_sc_hd__decap_3
X_7181_ _7372_/CLK _7181_/D _6461_/Y VGND VGND VPWR VPWR _7181_/Q sky130_fd_sc_hd__dfrtp_2
X_4393_ _7305_/Q _4914_/S _4434_/A2 _7113_/Q _4392_/X VGND VGND VPWR VPWR _4393_/X
+ sky130_fd_sc_hd__a221o_2
XFILLER_98_654 VGND VGND VPWR VPWR sky130_fd_sc_hd__decap_3
X_3344_ _3519_/B _5118_/D VGND VGND VPWR VPWR _3344_/Y sky130_fd_sc_hd__nor2_2
XTAP_TAPCELL_ROW_5_319 VGND VPWR sky130_fd_sc_hd__tapvpwrvgnd_1
XFILLER_100_626 VGND VGND VPWR VPWR sky130_fd_sc_hd__decap_3
XFILLER_112_464 VGND VGND VPWR VPWR sky130_fd_sc_hd__fill_1
XFILLER_97_153 VGND VGND VPWR VPWR sky130_fd_sc_hd__decap_3
XFILLER_97_186 VGND VGND VPWR VPWR sky130_fd_sc_hd__decap_3
XFILLER_98_687 VGND VGND VPWR VPWR sky130_fd_sc_hd__decap_3
Xhold1005 _7057_/Q VGND VGND VPWR VPWR _7057_/D sky130_fd_sc_hd__dlygate4sd3_1
XFILLER_100_648 VGND VGND VPWR VPWR sky130_fd_sc_hd__decap_3
XFILLER_38_220 VGND VGND VPWR VPWR sky130_fd_sc_hd__decap_3
Xhold1016 _6701_/Q VGND VGND VPWR VPWR _5703_/A1 sky130_fd_sc_hd__dlygate4sd3_1
Xhold1027 _7033_/Q VGND VGND VPWR VPWR _5589_/A sky130_fd_sc_hd__dlygate4sd3_1
Xhold1038 _7030_/Q VGND VGND VPWR VPWR _5595_/A sky130_fd_sc_hd__dlygate4sd3_1
Xhold1049 _7035_/Q VGND VGND VPWR VPWR _5586_/A1 sky130_fd_sc_hd__dlygate4sd3_1
X_5014_ _6990_/Q _5014_/B VGND VGND VPWR VPWR _5015_/C sky130_fd_sc_hd__or2_2
XFILLER_38_253 VGND VGND VPWR VPWR sky130_fd_sc_hd__decap_3
XFILLER_54_713 VGND VGND VPWR VPWR sky130_fd_sc_hd__fill_1
XFILLER_26_437 VGND VGND VPWR VPWR sky130_fd_sc_hd__decap_3
XFILLER_66_584 VGND VGND VPWR VPWR sky130_fd_sc_hd__decap_3
XFILLER_53_234 VGND VGND VPWR VPWR sky130_fd_sc_hd__decap_3
XFILLER_81_565 VGND VGND VPWR VPWR sky130_fd_sc_hd__fill_1
X_6965_ clkload9/A _6965_/D VGND VGND VPWR VPWR _6965_/Q sky130_fd_sc_hd__dfxtp_2
XTAP_TAPCELL_ROW_52_903 VGND VPWR sky130_fd_sc_hd__tapvpwrvgnd_1
XFILLER_22_610 VGND VGND VPWR VPWR sky130_fd_sc_hd__decap_3
XFILLER_53_267 VGND VGND VPWR VPWR sky130_fd_sc_hd__decap_3
XTAP_TAPCELL_ROW_52_914 VGND VPWR sky130_fd_sc_hd__tapvpwrvgnd_1
XTAP_TAPCELL_ROW_105_1574 VGND VPWR sky130_fd_sc_hd__tapvpwrvgnd_1
XFILLER_22_643 VGND VGND VPWR VPWR sky130_fd_sc_hd__fill_1
XFILLER_34_492 VGND VGND VPWR VPWR sky130_fd_sc_hd__fill_1
X_6896_ _6944_/CLK _6896_/D VGND VGND VPWR VPWR _6896_/Q sky130_fd_sc_hd__dfxtp_2
XFILLER_22_654 VGND VGND VPWR VPWR sky130_fd_sc_hd__decap_3
XFILLER_22_687 VGND VGND VPWR VPWR sky130_fd_sc_hd__decap_3
XFILLER_42_27 VGND VGND VPWR VPWR sky130_fd_sc_hd__fill_1
XTAP_TAPCELL_ROW_32_660 VGND VPWR sky130_fd_sc_hd__tapvpwrvgnd_1
XFILLER_21_197 VGND VGND VPWR VPWR sky130_fd_sc_hd__decap_3
XFILLER_108_704 VGND VGND VPWR VPWR sky130_fd_sc_hd__decap_3
XFILLER_5_308 VGND VGND VPWR VPWR sky130_fd_sc_hd__decap_3
X_4729_ _4836_/S _4729_/B VGND VGND VPWR VPWR _4729_/Y sky130_fd_sc_hd__nand2_2
XFILLER_1_514 VGND VGND VPWR VPWR sky130_fd_sc_hd__decap_3
XFILLER_89_632 VGND VGND VPWR VPWR sky130_fd_sc_hd__decap_3
X_7379_ _7388_/CLK _7379_/D _6659_/Y VGND VGND VPWR VPWR _7379_/Q sky130_fd_sc_hd__dfrtp_2
Xhold850 _6801_/Q VGND VGND VPWR VPWR _6801_/D sky130_fd_sc_hd__dlygate4sd3_1
Xhold861 _6826_/Q VGND VGND VPWR VPWR _6826_/D sky130_fd_sc_hd__dlygate4sd3_1
Xhold872 _6940_/Q VGND VGND VPWR VPWR _6940_/D sky130_fd_sc_hd__dlygate4sd3_1
XFILLER_103_420 VGND VGND VPWR VPWR sky130_fd_sc_hd__decap_3
XFILLER_107_75 VGND VGND VPWR VPWR sky130_fd_sc_hd__decap_3
XFILLER_1_547 VGND VGND VPWR VPWR sky130_fd_sc_hd__decap_3
XFILLER_88_120 VGND VGND VPWR VPWR sky130_fd_sc_hd__decap_3
XFILLER_89_665 VGND VGND VPWR VPWR sky130_fd_sc_hd__decap_3
Xhold883 _6881_/Q VGND VGND VPWR VPWR _6881_/D sky130_fd_sc_hd__dlygate4sd3_1
Xhold894 _6868_/Q VGND VGND VPWR VPWR _6868_/D sky130_fd_sc_hd__dlygate4sd3_1
XFILLER_103_464 VGND VGND VPWR VPWR sky130_fd_sc_hd__decap_3
XFILLER_67_57 VGND VGND VPWR VPWR sky130_fd_sc_hd__fill_2
XFILLER_88_153 VGND VGND VPWR VPWR sky130_fd_sc_hd__decap_3
XFILLER_89_676 VGND VGND VPWR VPWR sky130_fd_sc_hd__decap_3
XFILLER_29_220 VGND VGND VPWR VPWR sky130_fd_sc_hd__decap_3
XFILLER_76_326 VGND VGND VPWR VPWR sky130_fd_sc_hd__decap_3
XFILLER_88_186 VGND VGND VPWR VPWR sky130_fd_sc_hd__decap_3
XFILLER_88_197 VGND VGND VPWR VPWR sky130_fd_sc_hd__decap_3
XFILLER_29_264 VGND VGND VPWR VPWR sky130_fd_sc_hd__decap_3
XFILLER_57_551 VGND VGND VPWR VPWR sky130_fd_sc_hd__decap_3
XFILLER_91_318 VGND VGND VPWR VPWR sky130_fd_sc_hd__decap_3
XFILLER_17_415 VGND VGND VPWR VPWR sky130_fd_sc_hd__decap_3
XFILLER_17_437 VGND VGND VPWR VPWR sky130_fd_sc_hd__fill_2
XFILLER_72_510 VGND VGND VPWR VPWR sky130_fd_sc_hd__fill_1
XFILLER_83_78 VGND VGND VPWR VPWR sky130_fd_sc_hd__decap_3
XFILLER_25_470 VGND VGND VPWR VPWR sky130_fd_sc_hd__decap_3
XFILLER_32_418 VGND VGND VPWR VPWR sky130_fd_sc_hd__fill_2
XFILLER_44_267 VGND VGND VPWR VPWR sky130_fd_sc_hd__decap_3
XFILLER_12_120 VGND VGND VPWR VPWR sky130_fd_sc_hd__decap_3
XFILLER_13_632 VGND VGND VPWR VPWR sky130_fd_sc_hd__decap_3
XFILLER_13_665 VGND VGND VPWR VPWR sky130_fd_sc_hd__decap_3
XFILLER_13_676 VGND VGND VPWR VPWR sky130_fd_sc_hd__decap_3
XTAP_TAPCELL_ROW_80_1257 VGND VPWR sky130_fd_sc_hd__tapvpwrvgnd_1
XFILLER_9_603 VGND VGND VPWR VPWR sky130_fd_sc_hd__decap_3
XFILLER_9_647 VGND VGND VPWR VPWR sky130_fd_sc_hd__decap_3
XFILLER_114_707 VGND VGND VPWR VPWR sky130_fd_sc_hd__decap_3
XTAP_TAPCELL_ROW_10_387 VGND VPWR sky130_fd_sc_hd__tapvpwrvgnd_1
XFILLER_113_217 VGND VGND VPWR VPWR sky130_fd_sc_hd__fill_2
XFILLER_67_304 VGND VGND VPWR VPWR sky130_fd_sc_hd__fill_1
XFILLER_67_315 VGND VGND VPWR VPWR sky130_fd_sc_hd__decap_3
XFILLER_79_175 VGND VGND VPWR VPWR sky130_fd_sc_hd__decap_3
XFILLER_95_613 VGND VGND VPWR VPWR sky130_fd_sc_hd__decap_3
XTAP_TAPCELL_ROW_91_1397 VGND VPWR sky130_fd_sc_hd__tapvpwrvgnd_1
XFILLER_67_337 VGND VGND VPWR VPWR sky130_fd_sc_hd__decap_3
XFILLER_94_112 VGND VGND VPWR VPWR sky130_fd_sc_hd__decap_3
XFILLER_95_635 VGND VGND VPWR VPWR sky130_fd_sc_hd__decap_3
XFILLER_94_167 VGND VGND VPWR VPWR sky130_fd_sc_hd__decap_3
XFILLER_95_668 VGND VGND VPWR VPWR sky130_fd_sc_hd__decap_3
XFILLER_95_679 VGND VGND VPWR VPWR sky130_fd_sc_hd__decap_3
XFILLER_36_713 VGND VGND VPWR VPWR sky130_fd_sc_hd__fill_1
XFILLER_48_573 VGND VGND VPWR VPWR sky130_fd_sc_hd__fill_1
XFILLER_48_595 VGND VGND VPWR VPWR sky130_fd_sc_hd__decap_3
XFILLER_75_381 VGND VGND VPWR VPWR sky130_fd_sc_hd__decap_3
XFILLER_35_234 VGND VGND VPWR VPWR sky130_fd_sc_hd__decap_3
XFILLER_63_532 VGND VGND VPWR VPWR sky130_fd_sc_hd__decap_3
Xplace510 _3327_/B VGND VGND VPWR VPWR _3365_/A sky130_fd_sc_hd__buf_2
Xplace521 _6654_/A VGND VGND VPWR VPWR _6648_/A sky130_fd_sc_hd__buf_2
XFILLER_50_215 VGND VGND VPWR VPWR sky130_fd_sc_hd__decap_3
XFILLER_90_351 VGND VGND VPWR VPWR sky130_fd_sc_hd__decap_3
Xplace532 _6678_/A VGND VGND VPWR VPWR _6677_/A sky130_fd_sc_hd__buf_2
Xplace543 _6638_/A VGND VGND VPWR VPWR _6637_/A sky130_fd_sc_hd__buf_2
Xplace554 _6612_/A VGND VGND VPWR VPWR _6608_/A sky130_fd_sc_hd__buf_2
Xplace565 _6627_/A VGND VGND VPWR VPWR _6598_/A sky130_fd_sc_hd__buf_2
X_6750_ clkload7/A _6750_/D VGND VGND VPWR VPWR _6750_/Q sky130_fd_sc_hd__dfxtp_2
XFILLER_16_492 VGND VGND VPWR VPWR sky130_fd_sc_hd__decap_3
X_5701_ _7356_/Q _5701_/A1 _5737_/S VGND VGND VPWR VPWR _6700_/D sky130_fd_sc_hd__mux2_2
X_3962_ _7359_/Q _4505_/A0 _3975_/S VGND VGND VPWR VPWR _7359_/D sky130_fd_sc_hd__mux2_2
XTAP_TAPCELL_ROW_18_487 VGND VPWR sky130_fd_sc_hd__tapvpwrvgnd_1
XFILLER_50_259 VGND VGND VPWR VPWR sky130_fd_sc_hd__decap_3
X_6681_ _6683_/A VGND VGND VPWR VPWR _6681_/Y sky130_fd_sc_hd__inv_2
X_3893_ _6759_/Q _3910_/B1 _3893_/B1 _6753_/Q _3892_/X VGND VGND VPWR VPWR _3893_/X
+ sky130_fd_sc_hd__a221o_2
X_5632_ _5632_/A VGND VGND VPWR VPWR _5633_/A sky130_fd_sc_hd__inv_2
X_5563_ _5563_/A1 _5647_/A _4729_/B VGND VGND VPWR VPWR _7053_/D sky130_fd_sc_hd__a21bo_2
X_7302_ _7333_/CLK _7302_/D _6582_/Y VGND VGND VPWR VPWR _7302_/Q sky130_fd_sc_hd__dfrtp_2
XFILLER_117_556 VGND VGND VPWR VPWR sky130_fd_sc_hd__decap_3
XFILLER_104_217 VGND VGND VPWR VPWR sky130_fd_sc_hd__fill_1
X_7233_ _7400_/CLK _7233_/D _6513_/Y VGND VGND VPWR VPWR _7233_/Q sky130_fd_sc_hd__dfrtp_2
X_4445_ _4813_/A _4813_/B VGND VGND VPWR VPWR _4814_/B sky130_fd_sc_hd__nor2_2
XFILLER_104_239 VGND VGND VPWR VPWR sky130_fd_sc_hd__decap_3
X_7164_ _7362_/CLK _7164_/D _6444_/Y VGND VGND VPWR VPWR _7164_/Q sky130_fd_sc_hd__dfrtp_2
X_4376_ _4376_/A _4376_/B _4376_/C _4273_/D VGND VGND VPWR VPWR _4376_/X sky130_fd_sc_hd__or4b_2
X_3327_ _3371_/A _3327_/B VGND VGND VPWR VPWR _3328_/B sky130_fd_sc_hd__nor2_2
XFILLER_100_434 VGND VGND VPWR VPWR sky130_fd_sc_hd__decap_3
XFILLER_85_134 VGND VGND VPWR VPWR sky130_fd_sc_hd__decap_3
XFILLER_86_635 VGND VGND VPWR VPWR sky130_fd_sc_hd__decap_3
XFILLER_86_657 VGND VGND VPWR VPWR sky130_fd_sc_hd__decap_3
X_7095_ _7355_/CLK _7095_/D _6375_/Y VGND VGND VPWR VPWR _7095_/Q sky130_fd_sc_hd__dfrtp_2
XFILLER_37_49 VGND VGND VPWR VPWR sky130_fd_sc_hd__fill_2
XFILLER_73_307 VGND VGND VPWR VPWR sky130_fd_sc_hd__decap_3
XFILLER_85_167 VGND VGND VPWR VPWR sky130_fd_sc_hd__fill_1
XFILLER_26_212 VGND VGND VPWR VPWR sky130_fd_sc_hd__decap_3
XFILLER_54_510 VGND VGND VPWR VPWR sky130_fd_sc_hd__decap_3
XFILLER_73_329 VGND VGND VPWR VPWR sky130_fd_sc_hd__fill_2
XFILLER_85_189 VGND VGND VPWR VPWR sky130_fd_sc_hd__decap_3
XFILLER_94_690 VGND VGND VPWR VPWR sky130_fd_sc_hd__decap_3
XFILLER_54_554 VGND VGND VPWR VPWR sky130_fd_sc_hd__decap_3
XFILLER_81_340 VGND VGND VPWR VPWR sky130_fd_sc_hd__fill_1
XFILLER_14_418 VGND VGND VPWR VPWR sky130_fd_sc_hd__fill_2
XFILLER_26_256 VGND VGND VPWR VPWR sky130_fd_sc_hd__fill_2
XFILLER_26_278 VGND VGND VPWR VPWR sky130_fd_sc_hd__decap_3
XFILLER_54_565 VGND VGND VPWR VPWR sky130_fd_sc_hd__decap_3
XFILLER_54_587 VGND VGND VPWR VPWR sky130_fd_sc_hd__fill_1
XFILLER_53_37 VGND VGND VPWR VPWR sky130_fd_sc_hd__decap_3
X_6948_ _6968_/CLK _6948_/D VGND VGND VPWR VPWR _6948_/Q sky130_fd_sc_hd__dfxtp_2
X_6879_ _6942_/CLK _6879_/D VGND VGND VPWR VPWR _6879_/Q sky130_fd_sc_hd__dfxtp_2
XFILLER_10_613 VGND VGND VPWR VPWR sky130_fd_sc_hd__decap_3
XFILLER_22_473 VGND VGND VPWR VPWR sky130_fd_sc_hd__decap_3
XFILLER_10_657 VGND VGND VPWR VPWR sky130_fd_sc_hd__decap_3
XFILLER_108_523 VGND VGND VPWR VPWR sky130_fd_sc_hd__decap_3
XFILLER_6_628 VGND VGND VPWR VPWR sky130_fd_sc_hd__decap_3
XTAP_TAPCELL_ROW_118_1732 VGND VPWR sky130_fd_sc_hd__tapvpwrvgnd_1
XFILLER_108_578 VGND VGND VPWR VPWR sky130_fd_sc_hd__decap_3
XFILLER_118_41 VGND VGND VPWR VPWR sky130_fd_sc_hd__decap_3
XFILLER_108_589 VGND VGND VPWR VPWR sky130_fd_sc_hd__decap_3
XFILLER_118_74 VGND VGND VPWR VPWR sky130_fd_sc_hd__decap_3
XFILLER_118_85 VGND VGND VPWR VPWR sky130_fd_sc_hd__decap_3
XFILLER_1_333 VGND VGND VPWR VPWR sky130_fd_sc_hd__decap_3
XFILLER_103_261 VGND VGND VPWR VPWR sky130_fd_sc_hd__decap_3
XFILLER_1_366 VGND VGND VPWR VPWR sky130_fd_sc_hd__decap_3
Xhold691 _6796_/Q VGND VGND VPWR VPWR _6796_/D sky130_fd_sc_hd__dlygate4sd3_1
XFILLER_77_635 VGND VGND VPWR VPWR sky130_fd_sc_hd__decap_3
XFILLER_64_307 VGND VGND VPWR VPWR sky130_fd_sc_hd__fill_1
XFILLER_77_668 VGND VGND VPWR VPWR sky130_fd_sc_hd__decap_3
XFILLER_77_679 VGND VGND VPWR VPWR sky130_fd_sc_hd__decap_3
XFILLER_92_616 VGND VGND VPWR VPWR sky130_fd_sc_hd__decap_3
XFILLER_94_44 VGND VGND VPWR VPWR sky130_fd_sc_hd__fill_2
XFILLER_18_713 VGND VGND VPWR VPWR sky130_fd_sc_hd__fill_1
XFILLER_76_178 VGND VGND VPWR VPWR sky130_fd_sc_hd__fill_1
XFILLER_76_189 VGND VGND VPWR VPWR sky130_fd_sc_hd__decap_3
XTAP_TAPCELL_ROW_69_1119 VGND VPWR sky130_fd_sc_hd__tapvpwrvgnd_1
XFILLER_17_223 VGND VGND VPWR VPWR sky130_fd_sc_hd__fill_1
XFILLER_91_148 VGND VGND VPWR VPWR sky130_fd_sc_hd__decap_3
XFILLER_94_88 VGND VGND VPWR VPWR sky130_fd_sc_hd__decap_3
XFILLER_32_215 VGND VGND VPWR VPWR sky130_fd_sc_hd__decap_3
XFILLER_60_524 VGND VGND VPWR VPWR sky130_fd_sc_hd__decap_3
XFILLER_32_259 VGND VGND VPWR VPWR sky130_fd_sc_hd__decap_3
XTAP_TAPCELL_ROW_15_446 VGND VPWR sky130_fd_sc_hd__tapvpwrvgnd_1
XTAP_TAPCELL_ROW_43_799 VGND VPWR sky130_fd_sc_hd__tapvpwrvgnd_1
XFILLER_118_309 VGND VGND VPWR VPWR sky130_fd_sc_hd__fill_2
XFILLER_40_292 VGND VGND VPWR VPWR sky130_fd_sc_hd__decap_3
XFILLER_9_455 VGND VGND VPWR VPWR sky130_fd_sc_hd__decap_3
XFILLER_5_650 VGND VGND VPWR VPWR sky130_fd_sc_hd__decap_3
XTAP_TAPCELL_ROW_93_1415 VGND VPWR sky130_fd_sc_hd__tapvpwrvgnd_1
XFILLER_114_515 VGND VGND VPWR VPWR sky130_fd_sc_hd__decap_3
XTAP_TAPCELL_ROW_93_1426 VGND VPWR sky130_fd_sc_hd__tapvpwrvgnd_1
XFILLER_5_694 VGND VGND VPWR VPWR sky130_fd_sc_hd__decap_3
X_4230_ _7227_/Q _4307_/A2 _4335_/A2 _7291_/Q _4229_/X VGND VGND VPWR VPWR _4230_/X
+ sky130_fd_sc_hd__a221o_2
XFILLER_99_248 VGND VGND VPWR VPWR sky130_fd_sc_hd__decap_3
XFILLER_101_209 VGND VGND VPWR VPWR sky130_fd_sc_hd__decap_3
XFILLER_110_710 VGND VGND VPWR VPWR sky130_fd_sc_hd__decap_3
XFILLER_4_53 VGND VGND VPWR VPWR sky130_fd_sc_hd__decap_3
X_4161_ _7265_/Q _4422_/A2 _4421_/A2 _7233_/Q _4160_/X VGND VGND VPWR VPWR _4161_/X
+ sky130_fd_sc_hd__a221o_2
XFILLER_68_624 VGND VGND VPWR VPWR sky130_fd_sc_hd__decap_3
XFILLER_68_657 VGND VGND VPWR VPWR sky130_fd_sc_hd__decap_3
XFILLER_67_145 VGND VGND VPWR VPWR sky130_fd_sc_hd__decap_3
XFILLER_67_167 VGND VGND VPWR VPWR sky130_fd_sc_hd__fill_1
XFILLER_83_605 VGND VGND VPWR VPWR sky130_fd_sc_hd__decap_3
X_4092_ _7366_/Q _4394_/B _4436_/B1 _7174_/Q _4091_/X VGND VGND VPWR VPWR _4092_/X
+ sky130_fd_sc_hd__a221o_2
XFILLER_67_189 VGND VGND VPWR VPWR sky130_fd_sc_hd__decap_3
XFILLER_82_115 VGND VGND VPWR VPWR sky130_fd_sc_hd__decap_3
XFILLER_83_638 VGND VGND VPWR VPWR sky130_fd_sc_hd__decap_3
XFILLER_95_498 VGND VGND VPWR VPWR sky130_fd_sc_hd__decap_3
XFILLER_36_554 VGND VGND VPWR VPWR sky130_fd_sc_hd__decap_3
XFILLER_48_381 VGND VGND VPWR VPWR sky130_fd_sc_hd__decap_3
XFILLER_48_392 VGND VGND VPWR VPWR sky130_fd_sc_hd__decap_3
XFILLER_76_690 VGND VGND VPWR VPWR sky130_fd_sc_hd__decap_3
XFILLER_82_159 VGND VGND VPWR VPWR sky130_fd_sc_hd__fill_2
XFILLER_51_502 VGND VGND VPWR VPWR sky130_fd_sc_hd__fill_2
XFILLER_91_671 VGND VGND VPWR VPWR sky130_fd_sc_hd__fill_1
XFILLER_91_682 VGND VGND VPWR VPWR sky130_fd_sc_hd__decap_3
Xplace340 _5660_/B VGND VGND VPWR VPWR _3913_/B1 sky130_fd_sc_hd__buf_2
X_6802_ _6941_/CLK _6802_/D VGND VGND VPWR VPWR _6802_/Q sky130_fd_sc_hd__dfxtp_2
XFILLER_23_215 VGND VGND VPWR VPWR sky130_fd_sc_hd__decap_3
XFILLER_36_598 VGND VGND VPWR VPWR sky130_fd_sc_hd__decap_3
XFILLER_63_384 VGND VGND VPWR VPWR sky130_fd_sc_hd__decap_3
Xplace373 _3424_/S VGND VGND VPWR VPWR _4327_/A sky130_fd_sc_hd__buf_2
Xplace362 _3618_/X VGND VGND VPWR VPWR _4969_/B sky130_fd_sc_hd__buf_2
Xplace351 _3922_/A2 VGND VGND VPWR VPWR _3926_/B1 sky130_fd_sc_hd__buf_2
X_4994_ _5114_/A _4275_/A _4987_/A _5033_/B2 VGND VGND VPWR VPWR _4994_/X sky130_fd_sc_hd__a22o_2
XFILLER_23_248 VGND VGND VPWR VPWR sky130_fd_sc_hd__decap_3
Xplace395 _5427_/S VGND VGND VPWR VPWR _5402_/S sky130_fd_sc_hd__buf_2
Xplace384 _5708_/S VGND VGND VPWR VPWR _5737_/S sky130_fd_sc_hd__buf_2
X_6733_ clkload6/A _6733_/D VGND VGND VPWR VPWR _6733_/Q sky130_fd_sc_hd__dfxtp_2
X_3945_ _7367_/Q _4488_/A0 _3945_/S VGND VGND VPWR VPWR _7367_/D sky130_fd_sc_hd__mux2_2
XTAP_TAPCELL_ROW_102_1533 VGND VPWR sky130_fd_sc_hd__tapvpwrvgnd_1
X_6664_ _6664_/A VGND VGND VPWR VPWR _6664_/Y sky130_fd_sc_hd__inv_2
XFILLER_109_309 VGND VGND VPWR VPWR sky130_fd_sc_hd__decap_3
X_5615_ _7020_/Q _5633_/B VGND VGND VPWR VPWR _7020_/D sky130_fd_sc_hd__or2_2
X_3876_ _6858_/Q _3879_/B1 _3883_/B1 _6898_/Q VGND VGND VPWR VPWR _3876_/X sky130_fd_sc_hd__a22o_2
X_6595_ _6598_/A VGND VGND VPWR VPWR _6595_/Y sky130_fd_sc_hd__inv_2
XFILLER_105_537 VGND VGND VPWR VPWR sky130_fd_sc_hd__decap_3
X_7216_ _7355_/CLK _7216_/D _6496_/Y VGND VGND VPWR VPWR _7216_/Q sky130_fd_sc_hd__dfrtp_2
X_4428_ _7335_/Q _3945_/S _4428_/B1 _7143_/Q VGND VGND VPWR VPWR _4428_/X sky130_fd_sc_hd__a22o_2
XTAP_TAPCELL_ROW_113_1673 VGND VPWR sky130_fd_sc_hd__tapvpwrvgnd_1
XFILLER_113_570 VGND VGND VPWR VPWR sky130_fd_sc_hd__decap_3
XFILLER_59_635 VGND VGND VPWR VPWR sky130_fd_sc_hd__decap_3
XFILLER_86_421 VGND VGND VPWR VPWR sky130_fd_sc_hd__decap_3
XFILLER_98_281 VGND VGND VPWR VPWR sky130_fd_sc_hd__fill_2
X_7147_ _7371_/CLK _7147_/D _6427_/Y VGND VGND VPWR VPWR _7147_/Q sky130_fd_sc_hd__dfrtp_2
X_4359_ _4367_/C _4367_/A _4367_/B VGND VGND VPWR VPWR _5071_/B sky130_fd_sc_hd__nand3b_2
XFILLER_100_253 VGND VGND VPWR VPWR sky130_fd_sc_hd__decap_3
XFILLER_104_10 VGND VGND VPWR VPWR sky130_fd_sc_hd__decap_3
XFILLER_58_134 VGND VGND VPWR VPWR sky130_fd_sc_hd__decap_3
XFILLER_58_156 VGND VGND VPWR VPWR sky130_fd_sc_hd__decap_3
XFILLER_59_668 VGND VGND VPWR VPWR sky130_fd_sc_hd__decap_3
XFILLER_59_679 VGND VGND VPWR VPWR sky130_fd_sc_hd__decap_3
XFILLER_86_454 VGND VGND VPWR VPWR sky130_fd_sc_hd__decap_3
X_7078_ _7086_/CLK _7078_/D _6358_/Y VGND VGND VPWR VPWR _7078_/Q sky130_fd_sc_hd__dfrtp_2
XFILLER_46_329 VGND VGND VPWR VPWR sky130_fd_sc_hd__fill_2
XFILLER_58_178 VGND VGND VPWR VPWR sky130_fd_sc_hd__decap_3
XFILLER_73_104 VGND VGND VPWR VPWR sky130_fd_sc_hd__decap_3
XFILLER_74_627 VGND VGND VPWR VPWR sky130_fd_sc_hd__decap_3
XFILLER_64_25 VGND VGND VPWR VPWR sky130_fd_sc_hd__decap_3
XFILLER_73_148 VGND VGND VPWR VPWR sky130_fd_sc_hd__decap_3
XFILLER_42_502 VGND VGND VPWR VPWR sky130_fd_sc_hd__decap_3
XFILLER_82_660 VGND VGND VPWR VPWR sky130_fd_sc_hd__decap_3
XFILLER_14_215 VGND VGND VPWR VPWR sky130_fd_sc_hd__decap_3
XFILLER_42_524 VGND VGND VPWR VPWR sky130_fd_sc_hd__decap_3
XFILLER_82_693 VGND VGND VPWR VPWR sky130_fd_sc_hd__decap_3
XFILLER_14_259 VGND VGND VPWR VPWR sky130_fd_sc_hd__decap_3
XFILLER_80_35 VGND VGND VPWR VPWR sky130_fd_sc_hd__decap_3
XTAP_TAPCELL_ROW_12_405 VGND VPWR sky130_fd_sc_hd__tapvpwrvgnd_1
XFILLER_10_421 VGND VGND VPWR VPWR sky130_fd_sc_hd__decap_3
XFILLER_80_79 VGND VGND VPWR VPWR sky130_fd_sc_hd__decap_3
XTAP_TAPCELL_ROW_40_758 VGND VPWR sky130_fd_sc_hd__tapvpwrvgnd_1
XFILLER_6_447 VGND VGND VPWR VPWR sky130_fd_sc_hd__decap_3
XFILLER_89_55 VGND VGND VPWR VPWR sky130_fd_sc_hd__fill_1
XFILLER_2_631 VGND VGND VPWR VPWR sky130_fd_sc_hd__decap_3
XFILLER_89_88 VGND VGND VPWR VPWR sky130_fd_sc_hd__decap_3
XFILLER_2_675 VGND VGND VPWR VPWR sky130_fd_sc_hd__decap_3
XFILLER_104_570 VGND VGND VPWR VPWR sky130_fd_sc_hd__decap_3
XFILLER_104_592 VGND VGND VPWR VPWR sky130_fd_sc_hd__decap_3
XFILLER_77_432 VGND VGND VPWR VPWR sky130_fd_sc_hd__decap_3
XFILLER_89_281 VGND VGND VPWR VPWR sky130_fd_sc_hd__fill_2
XFILLER_89_292 VGND VGND VPWR VPWR sky130_fd_sc_hd__decap_3
XFILLER_49_145 VGND VGND VPWR VPWR sky130_fd_sc_hd__decap_3
XFILLER_37_307 VGND VGND VPWR VPWR sky130_fd_sc_hd__decap_3
XFILLER_49_189 VGND VGND VPWR VPWR sky130_fd_sc_hd__decap_3
XFILLER_64_104 VGND VGND VPWR VPWR sky130_fd_sc_hd__decap_3
XFILLER_65_638 VGND VGND VPWR VPWR sky130_fd_sc_hd__decap_3
XFILLER_58_690 VGND VGND VPWR VPWR sky130_fd_sc_hd__decap_3
XFILLER_64_126 VGND VGND VPWR VPWR sky130_fd_sc_hd__decap_3
XFILLER_64_159 VGND VGND VPWR VPWR sky130_fd_sc_hd__decap_3
XFILLER_92_435 VGND VGND VPWR VPWR sky130_fd_sc_hd__decap_3
XTAP_TAPCELL_ROW_48_858 VGND VPWR sky130_fd_sc_hd__tapvpwrvgnd_1
XFILLER_45_340 VGND VGND VPWR VPWR sky130_fd_sc_hd__decap_3
XFILLER_73_671 VGND VGND VPWR VPWR sky130_fd_sc_hd__fill_1
XFILLER_18_598 VGND VGND VPWR VPWR sky130_fd_sc_hd__decap_3
XFILLER_45_384 VGND VGND VPWR VPWR sky130_fd_sc_hd__decap_3
XFILLER_73_682 VGND VGND VPWR VPWR sky130_fd_sc_hd__decap_3
XFILLER_60_365 VGND VGND VPWR VPWR sky130_fd_sc_hd__fill_2
XFILLER_72_192 VGND VGND VPWR VPWR sky130_fd_sc_hd__decap_3
X_3730_ _6956_/Q _3910_/B1 _5660_/B _6950_/Q _3729_/X VGND VGND VPWR VPWR _3730_/X
+ sky130_fd_sc_hd__a221o_2
XFILLER_119_629 VGND VGND VPWR VPWR sky130_fd_sc_hd__decap_3
XFILLER_13_281 VGND VGND VPWR VPWR sky130_fd_sc_hd__fill_1
XFILLER_118_106 VGND VGND VPWR VPWR sky130_fd_sc_hd__fill_1
XFILLER_118_128 VGND VGND VPWR VPWR sky130_fd_sc_hd__decap_3
X_3661_ _3991_/B _3661_/B VGND VGND VPWR VPWR _3661_/X sky130_fd_sc_hd__and2_4
XFILLER_62_3 VGND VGND VPWR VPWR sky130_fd_sc_hd__decap_3
Xclkload11 _6922_/CLK VGND VGND VPWR VPWR clkload11/Y sky130_fd_sc_hd__inv_6
Xclkload22 _7390_/CLK VGND VGND VPWR VPWR clkload22/X sky130_fd_sc_hd__clkbuf_16
Xclkload33 _7387_/CLK VGND VGND VPWR VPWR clkload33/Y sky130_fd_sc_hd__clkinv_2
X_6380_ _6608_/A VGND VGND VPWR VPWR _6380_/Y sky130_fd_sc_hd__inv_2
X_5400_ _5400_/A0 _5011_/X _5402_/S VGND VGND VPWR VPWR _7133_/D sky130_fd_sc_hd__mux2_2
X_3592_ _4292_/B _3620_/C wire671/X VGND VGND VPWR VPWR _3592_/X sky130_fd_sc_hd__a21o_2
XFILLER_9_296 VGND VGND VPWR VPWR sky130_fd_sc_hd__decap_3
X_5331_ _5331_/A0 _5011_/X _5340_/S VGND VGND VPWR VPWR _7165_/D sky130_fd_sc_hd__mux2_2
XFILLER_5_491 VGND VGND VPWR VPWR sky130_fd_sc_hd__decap_3
XFILLER_102_507 VGND VGND VPWR VPWR sky130_fd_sc_hd__decap_3
X_7001_ _7373_/CLK _7001_/D _6281_/Y VGND VGND VPWR VPWR _7001_/Q sky130_fd_sc_hd__dfrtp_2
X_5262_ _5262_/A0 _4978_/X _5274_/S VGND VGND VPWR VPWR _7199_/D sky130_fd_sc_hd__mux2_2
XFILLER_68_410 VGND VGND VPWR VPWR sky130_fd_sc_hd__fill_1
X_4213_ _7292_/Q _4300_/B _4338_/B1 _7356_/Q _4347_/C1 VGND VGND VPWR VPWR _4213_/X
+ sky130_fd_sc_hd__a221o_2
XFILLER_68_454 VGND VGND VPWR VPWR sky130_fd_sc_hd__fill_1
X_4144_ _7362_/Q _4338_/B1 _4421_/B1 _7170_/Q VGND VGND VPWR VPWR _4144_/X sky130_fd_sc_hd__a22o_2
XFILLER_110_584 VGND VGND VPWR VPWR sky130_fd_sc_hd__decap_3
XFILLER_56_616 VGND VGND VPWR VPWR sky130_fd_sc_hd__decap_3
XFILLER_83_402 VGND VGND VPWR VPWR sky130_fd_sc_hd__decap_3
XFILLER_95_273 VGND VGND VPWR VPWR sky130_fd_sc_hd__decap_3
XFILLER_110_595 VGND VGND VPWR VPWR sky130_fd_sc_hd__decap_3
XFILLER_55_148 VGND VGND VPWR VPWR sky130_fd_sc_hd__decap_3
X_4075_ _7211_/Q _3945_/S _4865_/S _7307_/Q VGND VGND VPWR VPWR _4075_/X sky130_fd_sc_hd__a22o_2
XFILLER_55_159 VGND VGND VPWR VPWR sky130_fd_sc_hd__decap_3
XFILLER_64_660 VGND VGND VPWR VPWR sky130_fd_sc_hd__decap_3
XFILLER_83_479 VGND VGND VPWR VPWR sky130_fd_sc_hd__decap_3
XFILLER_24_546 VGND VGND VPWR VPWR sky130_fd_sc_hd__decap_3
XFILLER_51_310 VGND VGND VPWR VPWR sky130_fd_sc_hd__decap_3
XFILLER_64_693 VGND VGND VPWR VPWR sky130_fd_sc_hd__decap_3
XFILLER_63_192 VGND VGND VPWR VPWR sky130_fd_sc_hd__decap_3
X_6716_ _7086_/CLK _6716_/D VGND VGND VPWR VPWR _6716_/Q sky130_fd_sc_hd__dfxtp_2
X_4977_ _4977_/A _4977_/B VGND VGND VPWR VPWR _6993_/D sky130_fd_sc_hd__nor2_2
Xclkload5 clkload5/A VGND VGND VPWR VPWR clkload5/X sky130_fd_sc_hd__clkbuf_1
X_3928_ _3928_/A1 _5151_/A _3927_/X VGND VGND VPWR VPWR _7375_/D sky130_fd_sc_hd__o21a_2
XFILLER_109_106 VGND VGND VPWR VPWR sky130_fd_sc_hd__decap_3
X_6647_ _6647_/A VGND VGND VPWR VPWR _6647_/Y sky130_fd_sc_hd__inv_2
X_3859_ _6924_/Q _3921_/A2 _3922_/A2 _6788_/Q _3858_/X VGND VGND VPWR VPWR _3859_/X
+ sky130_fd_sc_hd__a221o_2
XFILLER_118_640 VGND VGND VPWR VPWR sky130_fd_sc_hd__decap_3
XFILLER_118_651 VGND VGND VPWR VPWR sky130_fd_sc_hd__decap_3
X_6578_ _6610_/A VGND VGND VPWR VPWR _6578_/Y sky130_fd_sc_hd__inv_2
XFILLER_105_301 VGND VGND VPWR VPWR sky130_fd_sc_hd__decap_3
XFILLER_117_161 VGND VGND VPWR VPWR sky130_fd_sc_hd__fill_2
XFILLER_118_684 VGND VGND VPWR VPWR sky130_fd_sc_hd__decap_3
XFILLER_3_417 VGND VGND VPWR VPWR sky130_fd_sc_hd__decap_3
XFILLER_117_172 VGND VGND VPWR VPWR sky130_fd_sc_hd__decap_3
XFILLER_105_367 VGND VGND VPWR VPWR sky130_fd_sc_hd__decap_3
XFILLER_59_47 VGND VGND VPWR VPWR sky130_fd_sc_hd__decap_3
XFILLER_78_218 VGND VGND VPWR VPWR sky130_fd_sc_hd__fill_1
XFILLER_105_389 VGND VGND VPWR VPWR sky130_fd_sc_hd__decap_3
Xoutput593 _5653_/Y VGND VGND VPWR VPWR alu_result_out[29] sky130_fd_sc_hd__clkdlybuf4s25_1
Xoutput582 _5656_/C VGND VGND VPWR VPWR alu_result_out[19] sky130_fd_sc_hd__clkdlybuf4s25_1
XFILLER_115_42 VGND VGND VPWR VPWR sky130_fd_sc_hd__decap_3
XFILLER_115_75 VGND VGND VPWR VPWR sky130_fd_sc_hd__decap_3
XFILLER_46_115 VGND VGND VPWR VPWR sky130_fd_sc_hd__fill_1
XFILLER_47_638 VGND VGND VPWR VPWR sky130_fd_sc_hd__decap_3
XFILLER_59_487 VGND VGND VPWR VPWR sky130_fd_sc_hd__fill_1
XFILLER_75_57 VGND VGND VPWR VPWR sky130_fd_sc_hd__decap_3
XFILLER_46_159 VGND VGND VPWR VPWR sky130_fd_sc_hd__decap_3
XFILLER_55_671 VGND VGND VPWR VPWR sky130_fd_sc_hd__fill_1
XFILLER_61_107 VGND VGND VPWR VPWR sky130_fd_sc_hd__decap_3
XTAP_TAPCELL_ROW_45_817 VGND VPWR sky130_fd_sc_hd__tapvpwrvgnd_1
XFILLER_42_321 VGND VGND VPWR VPWR sky130_fd_sc_hd__decap_3
XFILLER_55_682 VGND VGND VPWR VPWR sky130_fd_sc_hd__decap_3
XFILLER_54_192 VGND VGND VPWR VPWR sky130_fd_sc_hd__decap_3
XFILLER_70_663 VGND VGND VPWR VPWR sky130_fd_sc_hd__decap_3
XFILLER_91_34 VGND VGND VPWR VPWR sky130_fd_sc_hd__decap_3
XFILLER_42_365 VGND VGND VPWR VPWR sky130_fd_sc_hd__fill_2
XFILLER_42_376 VGND VGND VPWR VPWR sky130_fd_sc_hd__decap_3
XFILLER_70_696 VGND VGND VPWR VPWR sky130_fd_sc_hd__decap_3
XFILLER_91_89 VGND VGND VPWR VPWR sky130_fd_sc_hd__decap_3
XTAP_TAPCELL_ROW_25_574 VGND VPWR sky130_fd_sc_hd__tapvpwrvgnd_1
XFILLER_10_251 VGND VGND VPWR VPWR sky130_fd_sc_hd__fill_1
XFILLER_6_200 VGND VGND VPWR VPWR sky130_fd_sc_hd__decap_3
XFILLER_7_712 VGND VGND VPWR VPWR sky130_fd_sc_hd__fill_2
XTAP_TAPCELL_ROW_77_1218 VGND VPWR sky130_fd_sc_hd__tapvpwrvgnd_1
XFILLER_109_662 VGND VGND VPWR VPWR sky130_fd_sc_hd__decap_3
XFILLER_109_673 VGND VGND VPWR VPWR sky130_fd_sc_hd__decap_3
XFILLER_108_172 VGND VGND VPWR VPWR sky130_fd_sc_hd__decap_3
XFILLER_6_288 VGND VGND VPWR VPWR sky130_fd_sc_hd__fill_2
XFILLER_69_207 VGND VGND VPWR VPWR sky130_fd_sc_hd__fill_2
XFILLER_2_483 VGND VGND VPWR VPWR sky130_fd_sc_hd__decap_3
XFILLER_97_538 VGND VGND VPWR VPWR sky130_fd_sc_hd__decap_3
XFILLER_111_359 VGND VGND VPWR VPWR sky130_fd_sc_hd__decap_3
XFILLER_38_616 VGND VGND VPWR VPWR sky130_fd_sc_hd__decap_3
XTAP_TAPCELL_ROW_88_1358 VGND VPWR sky130_fd_sc_hd__tapvpwrvgnd_1
XFILLER_46_660 VGND VGND VPWR VPWR sky130_fd_sc_hd__decap_3
XFILLER_65_479 VGND VGND VPWR VPWR sky130_fd_sc_hd__decap_3
XFILLER_80_416 VGND VGND VPWR VPWR sky130_fd_sc_hd__decap_3
XFILLER_92_265 VGND VGND VPWR VPWR sky130_fd_sc_hd__decap_3
XFILLER_18_395 VGND VGND VPWR VPWR sky130_fd_sc_hd__decap_3
XFILLER_46_693 VGND VGND VPWR VPWR sky130_fd_sc_hd__decap_3
XFILLER_52_129 VGND VGND VPWR VPWR sky130_fd_sc_hd__decap_3
XFILLER_33_332 VGND VGND VPWR VPWR sky130_fd_sc_hd__decap_3
XFILLER_45_192 VGND VGND VPWR VPWR sky130_fd_sc_hd__fill_1
XFILLER_61_641 VGND VGND VPWR VPWR sky130_fd_sc_hd__decap_3
X_4831_ _4969_/B _4827_/X _4828_/X _4830_/X VGND VGND VPWR VPWR _5657_/A sky130_fd_sc_hd__a211o_2
XFILLER_21_505 VGND VGND VPWR VPWR sky130_fd_sc_hd__decap_3
XFILLER_60_173 VGND VGND VPWR VPWR sky130_fd_sc_hd__decap_3
XFILLER_61_685 VGND VGND VPWR VPWR sky130_fd_sc_hd__decap_3
XFILLER_21_549 VGND VGND VPWR VPWR sky130_fd_sc_hd__fill_1
XFILLER_60_195 VGND VGND VPWR VPWR sky130_fd_sc_hd__fill_1
X_4762_ _4762_/A _4762_/B VGND VGND VPWR VPWR _4762_/Y sky130_fd_sc_hd__nor2_2
X_6501_ _6593_/A VGND VGND VPWR VPWR _6501_/Y sky130_fd_sc_hd__inv_2
X_4693_ _7007_/Q _4750_/B VGND VGND VPWR VPWR _4728_/A sky130_fd_sc_hd__nand2_2
X_3713_ _3733_/C VGND VGND VPWR VPWR _3746_/C sky130_fd_sc_hd__inv_4
X_6432_ _6624_/A VGND VGND VPWR VPWR _6432_/Y sky130_fd_sc_hd__inv_2
X_3644_ _3629_/Y _3642_/X _4770_/A1 VGND VGND VPWR VPWR _4664_/B sky130_fd_sc_hd__o21a_2
XTAP_TAPCELL_ROW_99_1498 VGND VPWR sky130_fd_sc_hd__tapvpwrvgnd_1
XFILLER_115_632 VGND VGND VPWR VPWR sky130_fd_sc_hd__decap_3
X_6363_ _6649_/A VGND VGND VPWR VPWR _6363_/Y sky130_fd_sc_hd__inv_2
X_3575_ _7156_/Q _4339_/B1 _5229_/C _7124_/Q _3574_/X VGND VGND VPWR VPWR _3575_/X
+ sky130_fd_sc_hd__a221o_2
XFILLER_115_665 VGND VGND VPWR VPWR sky130_fd_sc_hd__decap_3
XFILLER_115_676 VGND VGND VPWR VPWR sky130_fd_sc_hd__decap_3
X_6294_ _6570_/A VGND VGND VPWR VPWR _6294_/Y sky130_fd_sc_hd__inv_2
XFILLER_102_315 VGND VGND VPWR VPWR sky130_fd_sc_hd__decap_3
XFILLER_88_527 VGND VGND VPWR VPWR sky130_fd_sc_hd__decap_3
X_5245_ _5245_/A0 _4836_/X _5272_/S VGND VGND VPWR VPWR _7207_/D sky130_fd_sc_hd__mux2_2
XTAP_TAPCELL_ROW_110_1632 VGND VPWR sky130_fd_sc_hd__tapvpwrvgnd_1
XFILLER_102_348 VGND VGND VPWR VPWR sky130_fd_sc_hd__decap_3
XFILLER_114_197 VGND VGND VPWR VPWR sky130_fd_sc_hd__fill_1
XFILLER_29_28 VGND VGND VPWR VPWR sky130_fd_sc_hd__fill_1
XFILLER_28_104 VGND VGND VPWR VPWR sky130_fd_sc_hd__fill_1
XFILLER_29_638 VGND VGND VPWR VPWR sky130_fd_sc_hd__decap_3
XFILLER_56_413 VGND VGND VPWR VPWR sky130_fd_sc_hd__decap_3
XFILLER_68_262 VGND VGND VPWR VPWR sky130_fd_sc_hd__decap_3
XFILLER_96_582 VGND VGND VPWR VPWR sky130_fd_sc_hd__fill_1
XFILLER_28_115 VGND VGND VPWR VPWR sky130_fd_sc_hd__decap_3
XFILLER_28_137 VGND VGND VPWR VPWR sky130_fd_sc_hd__decap_3
XFILLER_56_424 VGND VGND VPWR VPWR sky130_fd_sc_hd__decap_3
XFILLER_28_159 VGND VGND VPWR VPWR sky130_fd_sc_hd__decap_3
XFILLER_43_107 VGND VGND VPWR VPWR sky130_fd_sc_hd__decap_3
XFILLER_44_619 VGND VGND VPWR VPWR sky130_fd_sc_hd__decap_3
X_4058_ _7244_/Q _4430_/A2 _4459_/C1 _7180_/Q _4057_/X VGND VGND VPWR VPWR _4058_/X
+ sky130_fd_sc_hd__a221o_2
XPHY_EDGE_ROW_119_Left_239 VGND VGND VPWR VPWR sky130_fd_sc_hd__decap_3
XFILLER_36_170 VGND VGND VPWR VPWR sky130_fd_sc_hd__decap_3
XFILLER_37_671 VGND VGND VPWR VPWR sky130_fd_sc_hd__fill_1
XFILLER_37_682 VGND VGND VPWR VPWR sky130_fd_sc_hd__decap_3
XFILLER_24_332 VGND VGND VPWR VPWR sky130_fd_sc_hd__decap_3
XFILLER_52_663 VGND VGND VPWR VPWR sky130_fd_sc_hd__decap_3
XFILLER_101_55 VGND VGND VPWR VPWR sky130_fd_sc_hd__fill_1
XFILLER_24_365 VGND VGND VPWR VPWR sky130_fd_sc_hd__decap_3
XFILLER_51_140 VGND VGND VPWR VPWR sky130_fd_sc_hd__decap_3
XFILLER_52_696 VGND VGND VPWR VPWR sky130_fd_sc_hd__decap_3
XTAP_TAPCELL_ROW_61_1019 VGND VPWR sky130_fd_sc_hd__tapvpwrvgnd_1
XFILLER_24_398 VGND VGND VPWR VPWR sky130_fd_sc_hd__decap_3
XFILLER_51_184 VGND VGND VPWR VPWR sky130_fd_sc_hd__decap_3
XFILLER_61_26 VGND VGND VPWR VPWR sky130_fd_sc_hd__decap_3
XTAP_TAPCELL_ROW_22_533 VGND VPWR sky130_fd_sc_hd__tapvpwrvgnd_1
XTAP_TAPCELL_ROW_50_886 VGND VPWR sky130_fd_sc_hd__tapvpwrvgnd_1
XFILLER_20_571 VGND VGND VPWR VPWR sky130_fd_sc_hd__decap_3
XFILLER_106_610 VGND VGND VPWR VPWR sky130_fd_sc_hd__decap_3
XFILLER_4_704 VGND VGND VPWR VPWR sky130_fd_sc_hd__decap_3
XFILLER_106_643 VGND VGND VPWR VPWR sky130_fd_sc_hd__fill_1
XFILLER_3_225 VGND VGND VPWR VPWR sky130_fd_sc_hd__decap_3
XFILLER_105_153 VGND VGND VPWR VPWR sky130_fd_sc_hd__decap_3
XFILLER_106_654 VGND VGND VPWR VPWR sky130_fd_sc_hd__decap_3
XFILLER_3_258 VGND VGND VPWR VPWR sky130_fd_sc_hd__decap_3
XFILLER_79_505 VGND VGND VPWR VPWR sky130_fd_sc_hd__decap_3
XFILLER_105_175 VGND VGND VPWR VPWR sky130_fd_sc_hd__decap_3
XFILLER_106_687 VGND VGND VPWR VPWR sky130_fd_sc_hd__decap_3
XTAP_TAPCELL_ROW_72_1159 VGND VPWR sky130_fd_sc_hd__tapvpwrvgnd_1
XFILLER_75_700 VGND VGND VPWR VPWR sky130_fd_sc_hd__decap_3
XFILLER_86_67 VGND VGND VPWR VPWR sky130_fd_sc_hd__decap_3
XFILLER_101_370 VGND VGND VPWR VPWR sky130_fd_sc_hd__fill_1
XFILLER_19_83 VGND VGND VPWR VPWR sky130_fd_sc_hd__decap_3
XFILLER_59_284 VGND VGND VPWR VPWR sky130_fd_sc_hd__decap_3
XFILLER_28_660 VGND VGND VPWR VPWR sky130_fd_sc_hd__decap_3
XTAP_TAPCELL_ROW_58_986 VGND VPWR sky130_fd_sc_hd__tapvpwrvgnd_1
XFILLER_28_693 VGND VGND VPWR VPWR sky130_fd_sc_hd__decap_3
XFILLER_62_427 VGND VGND VPWR VPWR sky130_fd_sc_hd__decap_3
XTAP_TAPCELL_ROW_2_280 VGND VPWR sky130_fd_sc_hd__tapvpwrvgnd_1
XFILLER_27_181 VGND VGND VPWR VPWR sky130_fd_sc_hd__decap_3
XFILLER_27_192 VGND VGND VPWR VPWR sky130_fd_sc_hd__decap_3
XFILLER_35_60 VGND VGND VPWR VPWR sky130_fd_sc_hd__decap_3
XFILLER_43_641 VGND VGND VPWR VPWR sky130_fd_sc_hd__decap_3
XFILLER_55_490 VGND VGND VPWR VPWR sky130_fd_sc_hd__decap_3
XFILLER_15_365 VGND VGND VPWR VPWR sky130_fd_sc_hd__decap_3
XFILLER_30_313 VGND VGND VPWR VPWR sky130_fd_sc_hd__decap_3
XFILLER_35_93 VGND VGND VPWR VPWR sky130_fd_sc_hd__decap_3
XFILLER_43_685 VGND VGND VPWR VPWR sky130_fd_sc_hd__decap_3
XFILLER_42_184 VGND VGND VPWR VPWR sky130_fd_sc_hd__decap_3
XTAP_TAPCELL_ROW_83_1299 VGND VPWR sky130_fd_sc_hd__tapvpwrvgnd_1
XFILLER_30_357 VGND VGND VPWR VPWR sky130_fd_sc_hd__decap_3
XFILLER_11_582 VGND VGND VPWR VPWR sky130_fd_sc_hd__decap_3
XFILLER_7_520 VGND VGND VPWR VPWR sky130_fd_sc_hd__fill_1
XFILLER_7_542 VGND VGND VPWR VPWR sky130_fd_sc_hd__decap_3
XFILLER_116_429 VGND VGND VPWR VPWR sky130_fd_sc_hd__decap_3
XFILLER_7_564 VGND VGND VPWR VPWR sky130_fd_sc_hd__decap_3
XFILLER_7_597 VGND VGND VPWR VPWR sky130_fd_sc_hd__decap_3
X_3360_ _3327_/B _5129_/B _3371_/A VGND VGND VPWR VPWR _3386_/B sky130_fd_sc_hd__mux2_2
XFILLER_112_613 VGND VGND VPWR VPWR sky130_fd_sc_hd__decap_3
XFILLER_97_302 VGND VGND VPWR VPWR sky130_fd_sc_hd__decap_3
XFILLER_112_657 VGND VGND VPWR VPWR sky130_fd_sc_hd__decap_3
XFILLER_85_508 VGND VGND VPWR VPWR sky130_fd_sc_hd__decap_3
XFILLER_97_335 VGND VGND VPWR VPWR sky130_fd_sc_hd__fill_1
XFILLER_97_357 VGND VGND VPWR VPWR sky130_fd_sc_hd__decap_3
X_5030_ _6989_/Q _5044_/A VGND VGND VPWR VPWR _6989_/D sky130_fd_sc_hd__xor2_2
XFILLER_111_156 VGND VGND VPWR VPWR sky130_fd_sc_hd__decap_3
XFILLER_78_571 VGND VGND VPWR VPWR sky130_fd_sc_hd__decap_3
Xhold1209 _7163_/Q VGND VGND VPWR VPWR _5336_/A0 sky130_fd_sc_hd__dlygate4sd3_1
XFILLER_26_619 VGND VGND VPWR VPWR sky130_fd_sc_hd__decap_3
XFILLER_53_405 VGND VGND VPWR VPWR sky130_fd_sc_hd__decap_3
XFILLER_81_703 VGND VGND VPWR VPWR sky130_fd_sc_hd__decap_3
X_6981_ _6983_/CLK _6981_/D _6261_/Y VGND VGND VPWR VPWR _6981_/Q sky130_fd_sc_hd__dfrtp_2
XFILLER_18_170 VGND VGND VPWR VPWR sky130_fd_sc_hd__decap_3
XFILLER_19_671 VGND VGND VPWR VPWR sky130_fd_sc_hd__fill_1
XFILLER_19_682 VGND VGND VPWR VPWR sky130_fd_sc_hd__decap_3
XFILLER_93_585 VGND VGND VPWR VPWR sky130_fd_sc_hd__decap_3
XFILLER_53_449 VGND VGND VPWR VPWR sky130_fd_sc_hd__fill_2
XFILLER_80_246 VGND VGND VPWR VPWR sky130_fd_sc_hd__decap_3
XFILLER_34_663 VGND VGND VPWR VPWR sky130_fd_sc_hd__decap_3
XFILLER_34_696 VGND VGND VPWR VPWR sky130_fd_sc_hd__decap_3
XFILLER_61_460 VGND VGND VPWR VPWR sky130_fd_sc_hd__decap_3
XFILLER_80_279 VGND VGND VPWR VPWR sky130_fd_sc_hd__decap_3
XFILLER_21_313 VGND VGND VPWR VPWR sky130_fd_sc_hd__decap_3
XFILLER_21_346 VGND VGND VPWR VPWR sky130_fd_sc_hd__decap_3
XFILLER_33_184 VGND VGND VPWR VPWR sky130_fd_sc_hd__decap_3
X_4814_ _4814_/A _4814_/B VGND VGND VPWR VPWR _4814_/Y sky130_fd_sc_hd__nor2_2
XFILLER_21_368 VGND VGND VPWR VPWR sky130_fd_sc_hd__decap_3
X_4745_ _4745_/A VGND VGND VPWR VPWR _4745_/Y sky130_fd_sc_hd__inv_2
XFILLER_119_234 VGND VGND VPWR VPWR sky130_fd_sc_hd__decap_3
XFILLER_107_418 VGND VGND VPWR VPWR sky130_fd_sc_hd__decap_3
XFILLER_119_256 VGND VGND VPWR VPWR sky130_fd_sc_hd__decap_3
X_4676_ _5648_/A _5067_/B _6985_/Q _6986_/Q _6987_/Q VGND VGND VPWR VPWR _5045_/B
+ sky130_fd_sc_hd__o2111a_2
X_7395_ _7406_/CLK _7395_/D _6675_/Y VGND VGND VPWR VPWR _7395_/Q sky130_fd_sc_hd__dfrtp_2
X_6415_ _6641_/A VGND VGND VPWR VPWR _6415_/Y sky130_fd_sc_hd__inv_2
X_3627_ _3746_/A _3746_/B _3733_/C VGND VGND VPWR VPWR _5660_/A sky130_fd_sc_hd__and3_2
X_6346_ _6672_/A VGND VGND VPWR VPWR _6346_/Y sky130_fd_sc_hd__inv_2
X_3558_ _7061_/Q _3558_/B VGND VGND VPWR VPWR _3558_/X sky130_fd_sc_hd__or2_2
XFILLER_103_635 VGND VGND VPWR VPWR sky130_fd_sc_hd__decap_3
XFILLER_102_112 VGND VGND VPWR VPWR sky130_fd_sc_hd__decap_3
XFILLER_103_668 VGND VGND VPWR VPWR sky130_fd_sc_hd__decap_3
XFILLER_76_508 VGND VGND VPWR VPWR sky130_fd_sc_hd__decap_3
XFILLER_88_335 VGND VGND VPWR VPWR sky130_fd_sc_hd__decap_3
XFILLER_88_368 VGND VGND VPWR VPWR sky130_fd_sc_hd__decap_3
X_6277_ _6483_/A VGND VGND VPWR VPWR _6277_/Y sky130_fd_sc_hd__inv_2
X_3489_ _7311_/Q _4471_/S _4261_/A2 _7343_/Q _3488_/X VGND VGND VPWR VPWR _3489_/X
+ sky130_fd_sc_hd__a221o_2
XFILLER_103_679 VGND VGND VPWR VPWR sky130_fd_sc_hd__decap_3
XFILLER_29_402 VGND VGND VPWR VPWR sky130_fd_sc_hd__decap_3
XFILLER_57_700 VGND VGND VPWR VPWR sky130_fd_sc_hd__decap_3
X_5228_ _5238_/B VGND VGND VPWR VPWR _5229_/B sky130_fd_sc_hd__inv_2
XFILLER_102_189 VGND VGND VPWR VPWR sky130_fd_sc_hd__decap_3
XFILLER_29_435 VGND VGND VPWR VPWR sky130_fd_sc_hd__fill_1
X_5159_ _5159_/A0 _4470_/X _5159_/S VGND VGND VPWR VPWR _7247_/D sky130_fd_sc_hd__mux2_2
XFILLER_17_608 VGND VGND VPWR VPWR sky130_fd_sc_hd__decap_3
XFILLER_112_21 VGND VGND VPWR VPWR sky130_fd_sc_hd__decap_3
XFILLER_112_32 VGND VGND VPWR VPWR sky130_fd_sc_hd__decap_3
XFILLER_56_287 VGND VGND VPWR VPWR sky130_fd_sc_hd__decap_3
XFILLER_71_202 VGND VGND VPWR VPWR sky130_fd_sc_hd__decap_3
XFILLER_112_65 VGND VGND VPWR VPWR sky130_fd_sc_hd__decap_3
XFILLER_25_641 VGND VGND VPWR VPWR sky130_fd_sc_hd__decap_3
XFILLER_71_257 VGND VGND VPWR VPWR sky130_fd_sc_hd__fill_2
Xclkbuf_leaf_36_clk clkbuf_3_2__f_clk/X VGND VGND VPWR VPWR _7344_/CLK sky130_fd_sc_hd__clkbuf_16
XTAP_TAPCELL_ROW_55_945 VGND VPWR sky130_fd_sc_hd__tapvpwrvgnd_1
XFILLER_12_302 VGND VGND VPWR VPWR sky130_fd_sc_hd__decap_3
XFILLER_24_162 VGND VGND VPWR VPWR sky130_fd_sc_hd__decap_3
XFILLER_25_685 VGND VGND VPWR VPWR sky130_fd_sc_hd__decap_3
XFILLER_24_195 VGND VGND VPWR VPWR sky130_fd_sc_hd__fill_1
XFILLER_40_622 VGND VGND VPWR VPWR sky130_fd_sc_hd__decap_3
XTAP_TAPCELL_ROW_35_691 VGND VPWR sky130_fd_sc_hd__tapvpwrvgnd_1
XFILLER_12_357 VGND VGND VPWR VPWR sky130_fd_sc_hd__decap_3
XFILLER_12_368 VGND VGND VPWR VPWR sky130_fd_sc_hd__decap_3
XFILLER_40_666 VGND VGND VPWR VPWR sky130_fd_sc_hd__decap_3
XFILLER_40_699 VGND VGND VPWR VPWR sky130_fd_sc_hd__fill_1
XFILLER_8_339 VGND VGND VPWR VPWR sky130_fd_sc_hd__decap_3
XFILLER_21_40 VGND VGND VPWR VPWR sky130_fd_sc_hd__decap_3
XFILLER_4_501 VGND VGND VPWR VPWR sky130_fd_sc_hd__decap_3
XFILLER_4_512 VGND VGND VPWR VPWR sky130_fd_sc_hd__decap_3
XFILLER_4_545 VGND VGND VPWR VPWR sky130_fd_sc_hd__decap_3
XFILLER_4_578 VGND VGND VPWR VPWR sky130_fd_sc_hd__decap_3
XFILLER_4_589 VGND VGND VPWR VPWR sky130_fd_sc_hd__fill_2
XFILLER_79_335 VGND VGND VPWR VPWR sky130_fd_sc_hd__fill_1
XFILLER_79_346 VGND VGND VPWR VPWR sky130_fd_sc_hd__fill_2
XFILLER_79_357 VGND VGND VPWR VPWR sky130_fd_sc_hd__decap_3
XFILLER_97_66 VGND VGND VPWR VPWR sky130_fd_sc_hd__fill_1
XFILLER_97_77 VGND VGND VPWR VPWR sky130_fd_sc_hd__decap_3
XTAP_TAPCELL_ROW_7_350 VGND VPWR sky130_fd_sc_hd__tapvpwrvgnd_1
XFILLER_67_508 VGND VGND VPWR VPWR sky130_fd_sc_hd__fill_2
XFILLER_94_305 VGND VGND VPWR VPWR sky130_fd_sc_hd__decap_3
XFILLER_102_690 VGND VGND VPWR VPWR sky130_fd_sc_hd__decap_3
XFILLER_94_349 VGND VGND VPWR VPWR sky130_fd_sc_hd__decap_3
XFILLER_47_243 VGND VGND VPWR VPWR sky130_fd_sc_hd__decap_3
XFILLER_63_703 VGND VGND VPWR VPWR sky130_fd_sc_hd__decap_3
XFILLER_75_552 VGND VGND VPWR VPWR sky130_fd_sc_hd__decap_3
XFILLER_35_438 VGND VGND VPWR VPWR sky130_fd_sc_hd__fill_2
XFILLER_47_276 VGND VGND VPWR VPWR sky130_fd_sc_hd__decap_3
XFILLER_90_522 VGND VGND VPWR VPWR sky130_fd_sc_hd__fill_1
XTAP_TAPCELL_ROW_85_1317 VGND VPWR sky130_fd_sc_hd__tapvpwrvgnd_1
XFILLER_35_449 VGND VGND VPWR VPWR sky130_fd_sc_hd__decap_3
XFILLER_46_81 VGND VGND VPWR VPWR sky130_fd_sc_hd__decap_3
XFILLER_62_246 VGND VGND VPWR VPWR sky130_fd_sc_hd__fill_2
Xclkbuf_leaf_27_clk clkbuf_3_6__f_clk/X VGND VGND VPWR VPWR _7358_/CLK sky130_fd_sc_hd__clkbuf_16
XFILLER_16_663 VGND VGND VPWR VPWR sky130_fd_sc_hd__decap_3
XFILLER_16_696 VGND VGND VPWR VPWR sky130_fd_sc_hd__decap_3
XFILLER_30_121 VGND VGND VPWR VPWR sky130_fd_sc_hd__decap_3
XFILLER_31_644 VGND VGND VPWR VPWR sky130_fd_sc_hd__decap_3
XFILLER_43_482 VGND VGND VPWR VPWR sky130_fd_sc_hd__decap_3
XFILLER_31_688 VGND VGND VPWR VPWR sky130_fd_sc_hd__decap_3
XFILLER_116_204 VGND VGND VPWR VPWR sky130_fd_sc_hd__fill_2
X_4530_ _4530_/A0 _4597_/A0 _4532_/S VGND VGND VPWR VPWR _7314_/D sky130_fd_sc_hd__mux2_2
XTAP_TAPCELL_ROW_96_1457 VGND VPWR sky130_fd_sc_hd__tapvpwrvgnd_1
X_7180_ _7372_/CLK _7180_/D _6460_/Y VGND VGND VPWR VPWR _7180_/Q sky130_fd_sc_hd__dfrtp_2
X_3412_ _7187_/Q _3994_/S _4285_/B1 _7379_/Q VGND VGND VPWR VPWR _3412_/X sky130_fd_sc_hd__a22o_2
XFILLER_98_633 VGND VGND VPWR VPWR sky130_fd_sc_hd__decap_3
X_4392_ _7369_/Q _4394_/B _4434_/B1 _7145_/Q _4391_/X VGND VGND VPWR VPWR _4392_/X
+ sky130_fd_sc_hd__a221o_2
XFILLER_112_421 VGND VGND VPWR VPWR sky130_fd_sc_hd__fill_2
XFILLER_98_666 VGND VGND VPWR VPWR sky130_fd_sc_hd__decap_3
XFILLER_39_700 VGND VGND VPWR VPWR sky130_fd_sc_hd__decap_3
XFILLER_58_519 VGND VGND VPWR VPWR sky130_fd_sc_hd__fill_1
XFILLER_85_305 VGND VGND VPWR VPWR sky130_fd_sc_hd__decap_3
XFILLER_97_165 VGND VGND VPWR VPWR sky130_fd_sc_hd__decap_3
Xhold1006 _6702_/Q VGND VGND VPWR VPWR _5705_/A1 sky130_fd_sc_hd__dlygate4sd3_1
XFILLER_98_699 VGND VGND VPWR VPWR sky130_fd_sc_hd__fill_1
XFILLER_100_638 VGND VGND VPWR VPWR sky130_fd_sc_hd__decap_3
XFILLER_112_487 VGND VGND VPWR VPWR sky130_fd_sc_hd__decap_3
XFILLER_78_390 VGND VGND VPWR VPWR sky130_fd_sc_hd__decap_3
XFILLER_97_198 VGND VGND VPWR VPWR sky130_fd_sc_hd__decap_3
Xhold1017 _6689_/Q VGND VGND VPWR VPWR _5678_/A1 sky130_fd_sc_hd__dlygate4sd3_1
Xhold1028 _6700_/Q VGND VGND VPWR VPWR _5701_/A1 sky130_fd_sc_hd__dlygate4sd3_1
Xhold1039 _7043_/Q VGND VGND VPWR VPWR _5574_/A1 sky130_fd_sc_hd__dlygate4sd3_1
XFILLER_38_232 VGND VGND VPWR VPWR sky130_fd_sc_hd__decap_3
XFILLER_26_29 VGND VGND VPWR VPWR sky130_fd_sc_hd__fill_2
XFILLER_26_449 VGND VGND VPWR VPWR sky130_fd_sc_hd__decap_3
XFILLER_53_246 VGND VGND VPWR VPWR sky130_fd_sc_hd__decap_3
XFILLER_81_555 VGND VGND VPWR VPWR sky130_fd_sc_hd__fill_1
XFILLER_93_393 VGND VGND VPWR VPWR sky130_fd_sc_hd__decap_3
Xclkbuf_leaf_18_clk clkload2/A VGND VGND VPWR VPWR _7371_/CLK sky130_fd_sc_hd__clkbuf_16
X_6964_ _6983_/CLK _6964_/D VGND VGND VPWR VPWR _6964_/Q sky130_fd_sc_hd__dfxtp_2
XPHY_EDGE_ROW_5_Right_5 VGND VGND VPWR VPWR sky130_fd_sc_hd__decap_3
XFILLER_81_599 VGND VGND VPWR VPWR sky130_fd_sc_hd__decap_3
X_6895_ _6943_/CLK _6895_/D VGND VGND VPWR VPWR _6895_/Q sky130_fd_sc_hd__dfxtp_2
XTAP_TAPCELL_ROW_52_904 VGND VPWR sky130_fd_sc_hd__tapvpwrvgnd_1
XFILLER_22_622 VGND VGND VPWR VPWR sky130_fd_sc_hd__decap_3
XTAP_TAPCELL_ROW_105_1575 VGND VPWR sky130_fd_sc_hd__tapvpwrvgnd_1
XFILLER_22_666 VGND VGND VPWR VPWR sky130_fd_sc_hd__decap_3
XFILLER_21_165 VGND VGND VPWR VPWR sky130_fd_sc_hd__decap_3
XFILLER_22_699 VGND VGND VPWR VPWR sky130_fd_sc_hd__fill_1
XTAP_TAPCELL_ROW_32_661 VGND VPWR sky130_fd_sc_hd__tapvpwrvgnd_1
X_4728_ _4728_/A _4728_/B VGND VGND VPWR VPWR _4729_/B sky130_fd_sc_hd__nand2_2
XFILLER_107_204 VGND VGND VPWR VPWR sky130_fd_sc_hd__decap_3
X_4659_ _4814_/A _4457_/X _4658_/Y _4852_/A _4040_/Y VGND VGND VPWR VPWR _4659_/X
+ sky130_fd_sc_hd__o2111a_2
XFILLER_107_21 VGND VGND VPWR VPWR sky130_fd_sc_hd__decap_3
XFILLER_1_526 VGND VGND VPWR VPWR sky130_fd_sc_hd__decap_3
X_7378_ _7387_/CLK _7378_/D _6658_/Y VGND VGND VPWR VPWR _7378_/Q sky130_fd_sc_hd__dfrtp_2
Xhold840 _6878_/Q VGND VGND VPWR VPWR _6878_/D sky130_fd_sc_hd__dlygate4sd3_1
Xhold851 _6956_/Q VGND VGND VPWR VPWR _6956_/D sky130_fd_sc_hd__dlygate4sd3_1
Xhold862 _6781_/Q VGND VGND VPWR VPWR _6781_/D sky130_fd_sc_hd__dlygate4sd3_1
Xhold873 _6773_/Q VGND VGND VPWR VPWR _6773_/D sky130_fd_sc_hd__dlygate4sd3_1
XFILLER_103_432 VGND VGND VPWR VPWR sky130_fd_sc_hd__decap_3
XFILLER_1_559 VGND VGND VPWR VPWR sky130_fd_sc_hd__fill_1
XFILLER_88_132 VGND VGND VPWR VPWR sky130_fd_sc_hd__decap_3
XFILLER_89_644 VGND VGND VPWR VPWR sky130_fd_sc_hd__decap_3
Xhold884 _6964_/Q VGND VGND VPWR VPWR _6964_/D sky130_fd_sc_hd__dlygate4sd3_1
Xhold895 _6848_/Q VGND VGND VPWR VPWR _6848_/D sky130_fd_sc_hd__dlygate4sd3_1
X_6329_ _6676_/A VGND VGND VPWR VPWR _6329_/Y sky130_fd_sc_hd__inv_2
XFILLER_107_87 VGND VGND VPWR VPWR sky130_fd_sc_hd__decap_3
XFILLER_49_508 VGND VGND VPWR VPWR sky130_fd_sc_hd__decap_3
XFILLER_67_47 VGND VGND VPWR VPWR sky130_fd_sc_hd__fill_1
XFILLER_88_165 VGND VGND VPWR VPWR sky130_fd_sc_hd__decap_3
XFILLER_89_688 VGND VGND VPWR VPWR sky130_fd_sc_hd__decap_3
XFILLER_76_338 VGND VGND VPWR VPWR sky130_fd_sc_hd__decap_3
XFILLER_29_243 VGND VGND VPWR VPWR sky130_fd_sc_hd__decap_3
XFILLER_45_703 VGND VGND VPWR VPWR sky130_fd_sc_hd__decap_3
XFILLER_17_405 VGND VGND VPWR VPWR sky130_fd_sc_hd__fill_2
XFILLER_17_427 VGND VGND VPWR VPWR sky130_fd_sc_hd__decap_3
XFILLER_29_276 VGND VGND VPWR VPWR sky130_fd_sc_hd__decap_3
XFILLER_29_287 VGND VGND VPWR VPWR sky130_fd_sc_hd__decap_3
XFILLER_84_371 VGND VGND VPWR VPWR sky130_fd_sc_hd__decap_3
XFILLER_17_449 VGND VGND VPWR VPWR sky130_fd_sc_hd__decap_3
XFILLER_44_224 VGND VGND VPWR VPWR sky130_fd_sc_hd__decap_3
XFILLER_44_246 VGND VGND VPWR VPWR sky130_fd_sc_hd__decap_3
XFILLER_72_533 VGND VGND VPWR VPWR sky130_fd_sc_hd__decap_3
XFILLER_83_57 VGND VGND VPWR VPWR sky130_fd_sc_hd__decap_3
XFILLER_84_393 VGND VGND VPWR VPWR sky130_fd_sc_hd__decap_3
XFILLER_13_600 VGND VGND VPWR VPWR sky130_fd_sc_hd__decap_3
XFILLER_13_644 VGND VGND VPWR VPWR sky130_fd_sc_hd__decap_3
XFILLER_25_493 VGND VGND VPWR VPWR sky130_fd_sc_hd__fill_2
XFILLER_12_154 VGND VGND VPWR VPWR sky130_fd_sc_hd__decap_3
XTAP_TAPCELL_ROW_80_1258 VGND VPWR sky130_fd_sc_hd__tapvpwrvgnd_1
XFILLER_9_626 VGND VGND VPWR VPWR sky130_fd_sc_hd__decap_3
XFILLER_9_615 VGND VGND VPWR VPWR sky130_fd_sc_hd__fill_1
XFILLER_13_688 VGND VGND VPWR VPWR sky130_fd_sc_hd__decap_3
XFILLER_9_659 VGND VGND VPWR VPWR sky130_fd_sc_hd__decap_3
XFILLER_32_83 VGND VGND VPWR VPWR sky130_fd_sc_hd__fill_1
XTAP_TAPCELL_ROW_10_377 VGND VPWR sky130_fd_sc_hd__tapvpwrvgnd_1
XTAP_TAPCELL_ROW_10_388 VGND VPWR sky130_fd_sc_hd__tapvpwrvgnd_1
XFILLER_79_143 VGND VGND VPWR VPWR sky130_fd_sc_hd__decap_3
XFILLER_79_165 VGND VGND VPWR VPWR sky130_fd_sc_hd__decap_3
XTAP_TAPCELL_ROW_91_1398 VGND VPWR sky130_fd_sc_hd__tapvpwrvgnd_1
XFILLER_0_570 VGND VGND VPWR VPWR sky130_fd_sc_hd__decap_3
XFILLER_79_187 VGND VGND VPWR VPWR sky130_fd_sc_hd__fill_1
XFILLER_95_647 VGND VGND VPWR VPWR sky130_fd_sc_hd__decap_3
XFILLER_48_552 VGND VGND VPWR VPWR sky130_fd_sc_hd__decap_3
XFILLER_35_202 VGND VGND VPWR VPWR sky130_fd_sc_hd__decap_3
XFILLER_63_511 VGND VGND VPWR VPWR sky130_fd_sc_hd__fill_1
XFILLER_75_393 VGND VGND VPWR VPWR sky130_fd_sc_hd__decap_3
XFILLER_90_330 VGND VGND VPWR VPWR sky130_fd_sc_hd__decap_3
Xplace500 _3318_/B VGND VGND VPWR VPWR _4307_/A2 sky130_fd_sc_hd__buf_2
Xplace511 _6980_/Q VGND VGND VPWR VPWR _3327_/B sky130_fd_sc_hd__buf_2
Xplace522 _6654_/A VGND VGND VPWR VPWR _6550_/A sky130_fd_sc_hd__buf_2
XFILLER_16_460 VGND VGND VPWR VPWR sky130_fd_sc_hd__decap_3
XFILLER_23_408 VGND VGND VPWR VPWR sky130_fd_sc_hd__fill_2
XFILLER_51_706 VGND VGND VPWR VPWR sky130_fd_sc_hd__decap_3
XFILLER_90_363 VGND VGND VPWR VPWR sky130_fd_sc_hd__fill_1
XFILLER_90_374 VGND VGND VPWR VPWR sky130_fd_sc_hd__decap_3
Xplace533 _6680_/A VGND VGND VPWR VPWR _6678_/A sky130_fd_sc_hd__buf_2
Xplace544 _6641_/A VGND VGND VPWR VPWR _6638_/A sky130_fd_sc_hd__buf_2
Xplace555 _6631_/A VGND VGND VPWR VPWR _6636_/A sky130_fd_sc_hd__buf_2
XTAP_TAPCELL_ROW_18_477 VGND VPWR sky130_fd_sc_hd__tapvpwrvgnd_1
XFILLER_50_227 VGND VGND VPWR VPWR sky130_fd_sc_hd__decap_3
XFILLER_50_249 VGND VGND VPWR VPWR sky130_fd_sc_hd__decap_3
Xplace566 _6627_/A VGND VGND VPWR VPWR _6533_/A sky130_fd_sc_hd__buf_2
XTAP_TAPCELL_ROW_18_488 VGND VPWR sky130_fd_sc_hd__tapvpwrvgnd_1
XFILLER_31_441 VGND VGND VPWR VPWR sky130_fd_sc_hd__decap_3
XFILLER_31_452 VGND VGND VPWR VPWR sky130_fd_sc_hd__fill_1
XFILLER_43_290 VGND VGND VPWR VPWR sky130_fd_sc_hd__decap_3
XFILLER_92_3 VGND VGND VPWR VPWR sky130_fd_sc_hd__decap_3
X_6680_ _6680_/A VGND VGND VPWR VPWR _6680_/Y sky130_fd_sc_hd__inv_2
X_3892_ _6771_/Q _3892_/A2 _3665_/X _6765_/Q VGND VGND VPWR VPWR _3892_/X sky130_fd_sc_hd__a22o_2
XFILLER_31_485 VGND VGND VPWR VPWR sky130_fd_sc_hd__decap_3
XFILLER_8_681 VGND VGND VPWR VPWR sky130_fd_sc_hd__decap_3
X_7301_ _7333_/CLK _7301_/D _6581_/Y VGND VGND VPWR VPWR _7301_/Q sky130_fd_sc_hd__dfrtp_2
X_4513_ _4513_/A0 _7291_/Q _4532_/S VGND VGND VPWR VPWR _4513_/X sky130_fd_sc_hd__mux2_2
X_7232_ _7360_/CLK _7232_/D _6512_/Y VGND VGND VPWR VPWR _7232_/Q sky130_fd_sc_hd__dfrtp_2
Xclkbuf_leaf_7_clk clkbuf_leaf_9_clk/A VGND VGND VPWR VPWR _7390_/CLK sky130_fd_sc_hd__clkbuf_16
X_4444_ _4396_/A _4444_/B VGND VGND VPWR VPWR _4444_/X sky130_fd_sc_hd__and2b_2
XFILLER_98_430 VGND VGND VPWR VPWR sky130_fd_sc_hd__decap_3
X_7163_ _7354_/CLK _7163_/D _6443_/Y VGND VGND VPWR VPWR _7163_/Q sky130_fd_sc_hd__dfrtp_2
X_4375_ _5003_/A _4374_/X _4988_/A VGND VGND VPWR VPWR _4375_/X sky130_fd_sc_hd__o21ba_2
XFILLER_112_251 VGND VGND VPWR VPWR sky130_fd_sc_hd__fill_1
XFILLER_98_463 VGND VGND VPWR VPWR sky130_fd_sc_hd__decap_3
X_7094_ _7313_/CLK _7094_/D _6374_/Y VGND VGND VPWR VPWR _7094_/Q sky130_fd_sc_hd__dfrtp_2
X_3326_ _3326_/A _3326_/B VGND VGND VPWR VPWR _5238_/B sky130_fd_sc_hd__nor2_2
XFILLER_100_424 VGND VGND VPWR VPWR sky130_fd_sc_hd__decap_3
XFILLER_85_102 VGND VGND VPWR VPWR sky130_fd_sc_hd__decap_3
XFILLER_85_113 VGND VGND VPWR VPWR sky130_fd_sc_hd__decap_3
XFILLER_100_446 VGND VGND VPWR VPWR sky130_fd_sc_hd__decap_3
XFILLER_27_703 VGND VGND VPWR VPWR sky130_fd_sc_hd__decap_3
XFILLER_85_146 VGND VGND VPWR VPWR sky130_fd_sc_hd__decap_3
XFILLER_86_669 VGND VGND VPWR VPWR sky130_fd_sc_hd__decap_3
XFILLER_39_574 VGND VGND VPWR VPWR sky130_fd_sc_hd__decap_3
XFILLER_26_224 VGND VGND VPWR VPWR sky130_fd_sc_hd__decap_3
XFILLER_93_190 VGND VGND VPWR VPWR sky130_fd_sc_hd__decap_3
XTAP_TAPCELL_ROW_37_720 VGND VPWR sky130_fd_sc_hd__tapvpwrvgnd_1
XFILLER_81_352 VGND VGND VPWR VPWR sky130_fd_sc_hd__decap_3
XFILLER_81_374 VGND VGND VPWR VPWR sky130_fd_sc_hd__decap_3
XFILLER_81_396 VGND VGND VPWR VPWR sky130_fd_sc_hd__fill_2
X_6947_ clkload9/A _6947_/D VGND VGND VPWR VPWR _6947_/Q sky130_fd_sc_hd__dfxtp_2
XTAP_TAPCELL_ROW_66_1080 VGND VPWR sky130_fd_sc_hd__tapvpwrvgnd_1
XFILLER_22_430 VGND VGND VPWR VPWR sky130_fd_sc_hd__decap_3
X_6878_ _6923_/CLK _6878_/D VGND VGND VPWR VPWR _6878_/Q sky130_fd_sc_hd__dfxtp_2
XFILLER_10_625 VGND VGND VPWR VPWR sky130_fd_sc_hd__decap_3
XFILLER_108_502 VGND VGND VPWR VPWR sky130_fd_sc_hd__decap_3
XFILLER_10_669 VGND VGND VPWR VPWR sky130_fd_sc_hd__decap_3
XFILLER_6_607 VGND VGND VPWR VPWR sky130_fd_sc_hd__decap_3
XTAP_TAPCELL_ROW_118_1733 VGND VPWR sky130_fd_sc_hd__tapvpwrvgnd_1
XFILLER_118_53 VGND VGND VPWR VPWR sky130_fd_sc_hd__decap_3
XFILLER_1_301 VGND VGND VPWR VPWR sky130_fd_sc_hd__decap_3
XFILLER_118_97 VGND VGND VPWR VPWR sky130_fd_sc_hd__decap_3
XFILLER_89_430 VGND VGND VPWR VPWR sky130_fd_sc_hd__decap_3
XFILLER_103_240 VGND VGND VPWR VPWR sky130_fd_sc_hd__decap_3
XFILLER_78_68 VGND VGND VPWR VPWR sky130_fd_sc_hd__decap_3
XFILLER_89_452 VGND VGND VPWR VPWR sky130_fd_sc_hd__decap_3
Xhold692 _6738_/Q VGND VGND VPWR VPWR _6738_/D sky130_fd_sc_hd__dlygate4sd3_1
XFILLER_103_273 VGND VGND VPWR VPWR sky130_fd_sc_hd__fill_2
XFILLER_77_647 VGND VGND VPWR VPWR sky130_fd_sc_hd__decap_3
XFILLER_76_157 VGND VGND VPWR VPWR sky130_fd_sc_hd__decap_3
XFILLER_91_127 VGND VGND VPWR VPWR sky130_fd_sc_hd__decap_3
XFILLER_92_628 VGND VGND VPWR VPWR sky130_fd_sc_hd__decap_3
XFILLER_94_78 VGND VGND VPWR VPWR sky130_fd_sc_hd__decap_3
XFILLER_17_235 VGND VGND VPWR VPWR sky130_fd_sc_hd__fill_1
XFILLER_45_555 VGND VGND VPWR VPWR sky130_fd_sc_hd__fill_1
XFILLER_85_691 VGND VGND VPWR VPWR sky130_fd_sc_hd__decap_3
XFILLER_17_268 VGND VGND VPWR VPWR sky130_fd_sc_hd__decap_3
XFILLER_17_279 VGND VGND VPWR VPWR sky130_fd_sc_hd__fill_1
XFILLER_27_94 VGND VGND VPWR VPWR sky130_fd_sc_hd__fill_1
XFILLER_33_706 VGND VGND VPWR VPWR sky130_fd_sc_hd__decap_3
XFILLER_60_503 VGND VGND VPWR VPWR sky130_fd_sc_hd__decap_3
XFILLER_72_374 VGND VGND VPWR VPWR sky130_fd_sc_hd__decap_3
XFILLER_45_599 VGND VGND VPWR VPWR sky130_fd_sc_hd__decap_3
XFILLER_13_452 VGND VGND VPWR VPWR sky130_fd_sc_hd__fill_1
XFILLER_25_290 VGND VGND VPWR VPWR sky130_fd_sc_hd__decap_3
XFILLER_32_249 VGND VGND VPWR VPWR sky130_fd_sc_hd__decap_3
XTAP_TAPCELL_ROW_15_447 VGND VPWR sky130_fd_sc_hd__tapvpwrvgnd_1
XFILLER_40_271 VGND VGND VPWR VPWR sky130_fd_sc_hd__decap_3
XFILLER_9_423 VGND VGND VPWR VPWR sky130_fd_sc_hd__fill_1
XFILLER_9_445 VGND VGND VPWR VPWR sky130_fd_sc_hd__decap_3
XTAP_TAPCELL_ROW_93_1416 VGND VPWR sky130_fd_sc_hd__tapvpwrvgnd_1
XFILLER_114_527 VGND VGND VPWR VPWR sky130_fd_sc_hd__decap_3
XFILLER_4_150 VGND VGND VPWR VPWR sky130_fd_sc_hd__fill_2
XFILLER_5_662 VGND VGND VPWR VPWR sky130_fd_sc_hd__decap_3
XFILLER_5_673 VGND VGND VPWR VPWR sky130_fd_sc_hd__decap_3
XFILLER_4_32 VGND VGND VPWR VPWR sky130_fd_sc_hd__fill_1
XFILLER_68_603 VGND VGND VPWR VPWR sky130_fd_sc_hd__decap_3
X_4160_ _7297_/Q _4419_/A2 _4421_/B1 _7169_/Q _4159_/X VGND VGND VPWR VPWR _4160_/X
+ sky130_fd_sc_hd__a221o_2
XFILLER_67_124 VGND VGND VPWR VPWR sky130_fd_sc_hd__decap_3
XFILLER_68_636 VGND VGND VPWR VPWR sky130_fd_sc_hd__decap_3
XFILLER_95_411 VGND VGND VPWR VPWR sky130_fd_sc_hd__decap_3
XFILLER_68_669 VGND VGND VPWR VPWR sky130_fd_sc_hd__decap_3
X_4091_ _7110_/Q _4417_/B1 _4434_/B1 _7142_/Q _4090_/X VGND VGND VPWR VPWR _4091_/X
+ sky130_fd_sc_hd__a221o_2
XFILLER_48_371 VGND VGND VPWR VPWR sky130_fd_sc_hd__fill_1
XFILLER_83_617 VGND VGND VPWR VPWR sky130_fd_sc_hd__decap_3
XFILLER_75_190 VGND VGND VPWR VPWR sky130_fd_sc_hd__decap_3
XFILLER_82_127 VGND VGND VPWR VPWR sky130_fd_sc_hd__decap_3
XFILLER_91_650 VGND VGND VPWR VPWR sky130_fd_sc_hd__decap_3
Xplace330 _3892_/A2 VGND VGND VPWR VPWR _3912_/A2 sky130_fd_sc_hd__buf_2
X_6801_ _6941_/CLK _6801_/D VGND VGND VPWR VPWR _6801_/Q sky130_fd_sc_hd__dfxtp_2
XFILLER_90_160 VGND VGND VPWR VPWR sky130_fd_sc_hd__decap_3
XFILLER_91_694 VGND VGND VPWR VPWR sky130_fd_sc_hd__decap_3
Xplace363 _3586_/Y VGND VGND VPWR VPWR _3600_/A sky130_fd_sc_hd__buf_2
Xplace352 _3910_/B1 VGND VGND VPWR VPWR _3922_/A2 sky130_fd_sc_hd__buf_2
Xplace341 _3925_/A2 VGND VGND VPWR VPWR _3760_/B1 sky130_fd_sc_hd__buf_2
X_4993_ _4987_/A _4991_/Y _4992_/Y VGND VGND VPWR VPWR _4993_/X sky130_fd_sc_hd__o21a_2
Xplace396 _5429_/S VGND VGND VPWR VPWR _5427_/S sky130_fd_sc_hd__buf_2
Xplace385 _3423_/C VGND VGND VPWR VPWR _5708_/S sky130_fd_sc_hd__buf_2
Xplace374 _4131_/A2 VGND VGND VPWR VPWR _4437_/A2 sky130_fd_sc_hd__buf_2
X_6732_ clkload7/A _6732_/D VGND VGND VPWR VPWR _6732_/Q sky130_fd_sc_hd__dfxtp_2
XTAP_TAPCELL_ROW_102_1534 VGND VPWR sky130_fd_sc_hd__tapvpwrvgnd_1
X_6663_ _6664_/A VGND VGND VPWR VPWR _6663_/Y sky130_fd_sc_hd__inv_2
X_3875_ _3875_/A1 _5151_/A _3874_/X VGND VGND VPWR VPWR _7383_/D sky130_fd_sc_hd__o21a_2
X_6594_ _6635_/A VGND VGND VPWR VPWR _6594_/Y sky130_fd_sc_hd__inv_2
XFILLER_105_505 VGND VGND VPWR VPWR sky130_fd_sc_hd__decap_3
X_7215_ clkload8/A _7215_/D _6495_/Y VGND VGND VPWR VPWR _7215_/Q sky130_fd_sc_hd__dfrtp_2
XFILLER_101_700 VGND VGND VPWR VPWR sky130_fd_sc_hd__decap_3
XFILLER_59_614 VGND VGND VPWR VPWR sky130_fd_sc_hd__fill_2
X_7146_ _7403_/CLK _7146_/D _6426_/Y VGND VGND VPWR VPWR _7146_/Q sky130_fd_sc_hd__dfrtp_2
XTAP_TAPCELL_ROW_113_1674 VGND VPWR sky130_fd_sc_hd__tapvpwrvgnd_1
XFILLER_113_582 VGND VGND VPWR VPWR sky130_fd_sc_hd__decap_3
XFILLER_58_113 VGND VGND VPWR VPWR sky130_fd_sc_hd__decap_3
XFILLER_59_647 VGND VGND VPWR VPWR sky130_fd_sc_hd__decap_3
XFILLER_86_411 VGND VGND VPWR VPWR sky130_fd_sc_hd__decap_3
XFILLER_86_433 VGND VGND VPWR VPWR sky130_fd_sc_hd__decap_3
X_4358_ _4367_/A _4367_/B _4367_/C VGND VGND VPWR VPWR _5072_/B sky130_fd_sc_hd__a21bo_2
XFILLER_100_232 VGND VGND VPWR VPWR sky130_fd_sc_hd__decap_3
XFILLER_74_606 VGND VGND VPWR VPWR sky130_fd_sc_hd__decap_3
XFILLER_86_466 VGND VGND VPWR VPWR sky130_fd_sc_hd__decap_3
X_7077_ _7402_/CLK _7077_/D _6357_/Y VGND VGND VPWR VPWR _7077_/Q sky130_fd_sc_hd__dfrtp_2
X_4289_ _4289_/A _5737_/S VGND VGND VPWR VPWR _4649_/A sky130_fd_sc_hd__nand2_2
X_3309_ _3324_/A _3365_/A _6979_/Q VGND VGND VPWR VPWR _3383_/B sky130_fd_sc_hd__or3_4
XFILLER_100_265 VGND VGND VPWR VPWR sky130_fd_sc_hd__decap_3
XFILLER_104_22 VGND VGND VPWR VPWR sky130_fd_sc_hd__decap_3
XFILLER_27_500 VGND VGND VPWR VPWR sky130_fd_sc_hd__decap_3
XFILLER_27_511 VGND VGND VPWR VPWR sky130_fd_sc_hd__decap_3
XFILLER_39_360 VGND VGND VPWR VPWR sky130_fd_sc_hd__decap_3
XFILLER_58_168 VGND VGND VPWR VPWR sky130_fd_sc_hd__fill_1
XFILLER_73_116 VGND VGND VPWR VPWR sky130_fd_sc_hd__decap_3
XFILLER_74_639 VGND VGND VPWR VPWR sky130_fd_sc_hd__decap_3
XFILLER_86_477 VGND VGND VPWR VPWR sky130_fd_sc_hd__decap_3
XFILLER_100_287 VGND VGND VPWR VPWR sky130_fd_sc_hd__decap_3
XFILLER_104_88 VGND VGND VPWR VPWR sky130_fd_sc_hd__decap_3
XFILLER_39_382 VGND VGND VPWR VPWR sky130_fd_sc_hd__decap_3
XFILLER_39_393 VGND VGND VPWR VPWR sky130_fd_sc_hd__decap_3
XFILLER_67_691 VGND VGND VPWR VPWR sky130_fd_sc_hd__decap_3
XFILLER_15_706 VGND VGND VPWR VPWR sky130_fd_sc_hd__decap_3
XFILLER_54_363 VGND VGND VPWR VPWR sky130_fd_sc_hd__fill_1
XFILLER_82_672 VGND VGND VPWR VPWR sky130_fd_sc_hd__decap_3
XFILLER_27_588 VGND VGND VPWR VPWR sky130_fd_sc_hd__decap_3
XFILLER_54_396 VGND VGND VPWR VPWR sky130_fd_sc_hd__decap_3
XFILLER_80_47 VGND VGND VPWR VPWR sky130_fd_sc_hd__decap_3
XTAP_TAPCELL_ROW_12_406 VGND VPWR sky130_fd_sc_hd__tapvpwrvgnd_1
XFILLER_22_271 VGND VGND VPWR VPWR sky130_fd_sc_hd__decap_3
XFILLER_22_293 VGND VGND VPWR VPWR sky130_fd_sc_hd__fill_1
XTAP_TAPCELL_ROW_40_759 VGND VPWR sky130_fd_sc_hd__tapvpwrvgnd_1
XFILLER_10_477 VGND VGND VPWR VPWR sky130_fd_sc_hd__decap_3
XFILLER_108_343 VGND VGND VPWR VPWR sky130_fd_sc_hd__decap_3
XFILLER_10_488 VGND VGND VPWR VPWR sky130_fd_sc_hd__decap_3
XFILLER_2_610 VGND VGND VPWR VPWR sky130_fd_sc_hd__decap_3
XFILLER_97_709 VGND VGND VPWR VPWR sky130_fd_sc_hd__decap_3
XFILLER_111_508 VGND VGND VPWR VPWR sky130_fd_sc_hd__decap_3
XFILLER_2_643 VGND VGND VPWR VPWR sky130_fd_sc_hd__fill_1
XFILLER_2_654 VGND VGND VPWR VPWR sky130_fd_sc_hd__decap_3
XFILLER_104_560 VGND VGND VPWR VPWR sky130_fd_sc_hd__decap_3
XFILLER_2_687 VGND VGND VPWR VPWR sky130_fd_sc_hd__decap_3
XFILLER_77_411 VGND VGND VPWR VPWR sky130_fd_sc_hd__decap_3
XFILLER_89_271 VGND VGND VPWR VPWR sky130_fd_sc_hd__decap_3
XFILLER_65_606 VGND VGND VPWR VPWR sky130_fd_sc_hd__decap_3
XFILLER_77_455 VGND VGND VPWR VPWR sky130_fd_sc_hd__decap_3
XFILLER_18_500 VGND VGND VPWR VPWR sky130_fd_sc_hd__decap_3
XFILLER_37_319 VGND VGND VPWR VPWR sky130_fd_sc_hd__decap_3
XFILLER_64_116 VGND VGND VPWR VPWR sky130_fd_sc_hd__fill_2
XFILLER_65_617 VGND VGND VPWR VPWR sky130_fd_sc_hd__decap_3
XFILLER_77_488 VGND VGND VPWR VPWR sky130_fd_sc_hd__decap_3
XFILLER_92_403 VGND VGND VPWR VPWR sky130_fd_sc_hd__decap_3
XFILLER_38_82 VGND VGND VPWR VPWR sky130_fd_sc_hd__fill_2
XFILLER_64_138 VGND VGND VPWR VPWR sky130_fd_sc_hd__fill_2
XFILLER_92_447 VGND VGND VPWR VPWR sky130_fd_sc_hd__decap_3
XTAP_TAPCELL_ROW_48_859 VGND VPWR sky130_fd_sc_hd__tapvpwrvgnd_1
XFILLER_18_577 VGND VGND VPWR VPWR sky130_fd_sc_hd__decap_3
XFILLER_45_352 VGND VGND VPWR VPWR sky130_fd_sc_hd__decap_3
XFILLER_73_650 VGND VGND VPWR VPWR sky130_fd_sc_hd__decap_3
XFILLER_80_609 VGND VGND VPWR VPWR sky130_fd_sc_hd__decap_3
XFILLER_60_300 VGND VGND VPWR VPWR sky130_fd_sc_hd__decap_3
XFILLER_72_171 VGND VGND VPWR VPWR sky130_fd_sc_hd__decap_3
XFILLER_73_694 VGND VGND VPWR VPWR sky130_fd_sc_hd__decap_3
XFILLER_21_709 VGND VGND VPWR VPWR sky130_fd_sc_hd__decap_3
XFILLER_60_344 VGND VGND VPWR VPWR sky130_fd_sc_hd__decap_3
XFILLER_60_377 VGND VGND VPWR VPWR sky130_fd_sc_hd__decap_3
XFILLER_41_591 VGND VGND VPWR VPWR sky130_fd_sc_hd__decap_3
XFILLER_9_264 VGND VGND VPWR VPWR sky130_fd_sc_hd__decap_3
XFILLER_70_91 VGND VGND VPWR VPWR sky130_fd_sc_hd__decap_3
Xclkload12 _7189_/CLK VGND VGND VPWR VPWR clkload12/X sky130_fd_sc_hd__clkbuf_8
Xclkload23 _6944_/CLK VGND VGND VPWR VPWR clkload23/X sky130_fd_sc_hd__clkbuf_1
Xclkload34 _7371_/CLK VGND VGND VPWR VPWR clkload34/Y sky130_fd_sc_hd__clkinv_2
X_3591_ _3591_/A _3591_/B _3591_/C _3586_/D VGND VGND VPWR VPWR _3591_/Y sky130_fd_sc_hd__nor4b_2
XFILLER_5_470 VGND VGND VPWR VPWR sky130_fd_sc_hd__decap_3
XFILLER_102_519 VGND VGND VPWR VPWR sky130_fd_sc_hd__decap_3
XFILLER_87_208 VGND VGND VPWR VPWR sky130_fd_sc_hd__decap_3
X_7000_ _7373_/CLK _7000_/D _6280_/Y VGND VGND VPWR VPWR _7000_/Q sky130_fd_sc_hd__dfrtp_2
X_4212_ _7324_/Q _3964_/S _4263_/A2 _7132_/Q VGND VGND VPWR VPWR _4212_/X sky130_fd_sc_hd__a22o_2
X_5192_ _5192_/A _5207_/B VGND VGND VPWR VPWR _7232_/D sky130_fd_sc_hd__and2_2
XFILLER_110_530 VGND VGND VPWR VPWR sky130_fd_sc_hd__fill_2
X_4143_ _4845_/A _4140_/X _4142_/X VGND VGND VPWR VPWR _4143_/X sky130_fd_sc_hd__a21o_2
XFILLER_55_116 VGND VGND VPWR VPWR sky130_fd_sc_hd__fill_1
XFILLER_56_628 VGND VGND VPWR VPWR sky130_fd_sc_hd__decap_3
XFILLER_68_477 VGND VGND VPWR VPWR sky130_fd_sc_hd__decap_3
X_4074_ _7083_/Q _4102_/B _4432_/B1 _4073_/X VGND VGND VPWR VPWR _4451_/A sky130_fd_sc_hd__o211ai_2
XFILLER_49_691 VGND VGND VPWR VPWR sky130_fd_sc_hd__decap_3
XFILLER_83_447 VGND VGND VPWR VPWR sky130_fd_sc_hd__fill_1
XFILLER_83_458 VGND VGND VPWR VPWR sky130_fd_sc_hd__fill_2
XFILLER_48_190 VGND VGND VPWR VPWR sky130_fd_sc_hd__decap_3
XFILLER_64_672 VGND VGND VPWR VPWR sky130_fd_sc_hd__decap_3
XFILLER_24_536 VGND VGND VPWR VPWR sky130_fd_sc_hd__decap_3
XFILLER_51_322 VGND VGND VPWR VPWR sky130_fd_sc_hd__decap_3
XFILLER_91_480 VGND VGND VPWR VPWR sky130_fd_sc_hd__decap_3
X_6715_ _7086_/CLK _6715_/D VGND VGND VPWR VPWR _6715_/Q sky130_fd_sc_hd__dfxtp_2
X_4976_ _6992_/Q _5001_/A _6993_/Q VGND VGND VPWR VPWR _4977_/B sky130_fd_sc_hd__a21oi_2
XTAP_TAPCELL_ROW_63_1050 VGND VPWR sky130_fd_sc_hd__tapvpwrvgnd_1
XFILLER_51_399 VGND VGND VPWR VPWR sky130_fd_sc_hd__fill_1
X_3927_ _3682_/A _3926_/X _4791_/A1 VGND VGND VPWR VPWR _3927_/X sky130_fd_sc_hd__a21o_2
Xclkload6 clkload6/A VGND VGND VPWR VPWR clkload6/X sky130_fd_sc_hd__clkbuf_8
X_6646_ _6680_/A VGND VGND VPWR VPWR _6646_/Y sky130_fd_sc_hd__inv_2
X_3858_ _6698_/Q _3925_/A2 _3922_/B1 _6876_/Q VGND VGND VPWR VPWR _3858_/X sky130_fd_sc_hd__a22o_2
X_6577_ _6610_/A VGND VGND VPWR VPWR _6577_/Y sky130_fd_sc_hd__inv_2
X_3789_ _3728_/Y _3781_/X _3783_/X _3725_/X _3788_/X VGND VGND VPWR VPWR _3789_/X
+ sky130_fd_sc_hd__a221o_2
XFILLER_118_663 VGND VGND VPWR VPWR sky130_fd_sc_hd__decap_3
XFILLER_105_313 VGND VGND VPWR VPWR sky130_fd_sc_hd__decap_3
XFILLER_105_335 VGND VGND VPWR VPWR sky130_fd_sc_hd__fill_1
XFILLER_118_696 VGND VGND VPWR VPWR sky130_fd_sc_hd__decap_3
XFILLER_105_346 VGND VGND VPWR VPWR sky130_fd_sc_hd__decap_3
XFILLER_79_709 VGND VGND VPWR VPWR sky130_fd_sc_hd__decap_3
Xoutput572 _5650_/Y VGND VGND VPWR VPWR alu_result_out[0] sky130_fd_sc_hd__clkdlybuf4s25_1
XFILLER_115_21 VGND VGND VPWR VPWR sky130_fd_sc_hd__decap_3
XFILLER_59_411 VGND VGND VPWR VPWR sky130_fd_sc_hd__decap_3
Xoutput594 _3634_/Y VGND VGND VPWR VPWR alu_result_out[2] sky130_fd_sc_hd__clkdlybuf4s25_1
Xoutput583 _5659_/B VGND VGND VPWR VPWR alu_result_out[1] sky130_fd_sc_hd__clkdlybuf4s25_1
XFILLER_99_591 VGND VGND VPWR VPWR sky130_fd_sc_hd__fill_1
XFILLER_101_530 VGND VGND VPWR VPWR sky130_fd_sc_hd__decap_3
XFILLER_113_390 VGND VGND VPWR VPWR sky130_fd_sc_hd__fill_2
XFILLER_115_54 VGND VGND VPWR VPWR sky130_fd_sc_hd__fill_2
XFILLER_59_433 VGND VGND VPWR VPWR sky130_fd_sc_hd__decap_3
XFILLER_59_455 VGND VGND VPWR VPWR sky130_fd_sc_hd__decap_3
XFILLER_86_230 VGND VGND VPWR VPWR sky130_fd_sc_hd__decap_3
X_7129_ _7354_/CLK _7129_/D _6409_/Y VGND VGND VPWR VPWR _7129_/Q sky130_fd_sc_hd__dfrtp_2
XFILLER_115_87 VGND VGND VPWR VPWR sky130_fd_sc_hd__decap_3
XFILLER_19_319 VGND VGND VPWR VPWR sky130_fd_sc_hd__decap_3
XFILLER_47_617 VGND VGND VPWR VPWR sky130_fd_sc_hd__decap_3
XFILLER_101_596 VGND VGND VPWR VPWR sky130_fd_sc_hd__decap_3
XFILLER_46_149 VGND VGND VPWR VPWR sky130_fd_sc_hd__fill_1
XFILLER_59_499 VGND VGND VPWR VPWR sky130_fd_sc_hd__decap_3
XFILLER_74_458 VGND VGND VPWR VPWR sky130_fd_sc_hd__fill_1
XFILLER_86_285 VGND VGND VPWR VPWR sky130_fd_sc_hd__decap_3
XFILLER_27_330 VGND VGND VPWR VPWR sky130_fd_sc_hd__fill_1
XFILLER_27_352 VGND VGND VPWR VPWR sky130_fd_sc_hd__decap_3
XFILLER_55_650 VGND VGND VPWR VPWR sky130_fd_sc_hd__decap_3
XTAP_TAPCELL_ROW_45_818 VGND VPWR sky130_fd_sc_hd__tapvpwrvgnd_1
XFILLER_15_525 VGND VGND VPWR VPWR sky130_fd_sc_hd__decap_3
XFILLER_27_374 VGND VGND VPWR VPWR sky130_fd_sc_hd__fill_1
XFILLER_54_171 VGND VGND VPWR VPWR sky130_fd_sc_hd__decap_3
XFILLER_55_694 VGND VGND VPWR VPWR sky130_fd_sc_hd__decap_3
XFILLER_61_119 VGND VGND VPWR VPWR sky130_fd_sc_hd__decap_3
XFILLER_82_480 VGND VGND VPWR VPWR sky130_fd_sc_hd__fill_2
XFILLER_15_547 VGND VGND VPWR VPWR sky130_fd_sc_hd__decap_3
XFILLER_15_569 VGND VGND VPWR VPWR sky130_fd_sc_hd__decap_3
XFILLER_70_631 VGND VGND VPWR VPWR sky130_fd_sc_hd__decap_3
XFILLER_91_46 VGND VGND VPWR VPWR sky130_fd_sc_hd__fill_2
XFILLER_30_528 VGND VGND VPWR VPWR sky130_fd_sc_hd__decap_3
XFILLER_70_675 VGND VGND VPWR VPWR sky130_fd_sc_hd__decap_3
XFILLER_91_68 VGND VGND VPWR VPWR sky130_fd_sc_hd__decap_3
XTAP_TAPCELL_ROW_25_575 VGND VPWR sky130_fd_sc_hd__tapvpwrvgnd_1
XFILLER_23_591 VGND VGND VPWR VPWR sky130_fd_sc_hd__decap_3
XFILLER_24_62 VGND VGND VPWR VPWR sky130_fd_sc_hd__decap_3
XFILLER_109_641 VGND VGND VPWR VPWR sky130_fd_sc_hd__decap_3
XFILLER_6_223 VGND VGND VPWR VPWR sky130_fd_sc_hd__decap_3
XTAP_TAPCELL_ROW_77_1219 VGND VPWR sky130_fd_sc_hd__tapvpwrvgnd_1
XFILLER_109_685 VGND VGND VPWR VPWR sky130_fd_sc_hd__decap_3
XFILLER_6_245 VGND VGND VPWR VPWR sky130_fd_sc_hd__decap_3
XFILLER_6_256 VGND VGND VPWR VPWR sky130_fd_sc_hd__decap_3
XFILLER_108_184 VGND VGND VPWR VPWR sky130_fd_sc_hd__decap_3
XFILLER_40_94 VGND VGND VPWR VPWR sky130_fd_sc_hd__fill_2
XFILLER_2_473 VGND VGND VPWR VPWR sky130_fd_sc_hd__decap_3
XFILLER_2_495 VGND VGND VPWR VPWR sky130_fd_sc_hd__decap_3
XFILLER_1_11 VGND VGND VPWR VPWR sky130_fd_sc_hd__fill_1
XFILLER_37_105 VGND VGND VPWR VPWR sky130_fd_sc_hd__decap_3
XFILLER_38_628 VGND VGND VPWR VPWR sky130_fd_sc_hd__decap_3
XFILLER_49_92 VGND VGND VPWR VPWR sky130_fd_sc_hd__fill_2
XFILLER_92_200 VGND VGND VPWR VPWR sky130_fd_sc_hd__decap_3
XFILLER_93_712 VGND VGND VPWR VPWR sky130_fd_sc_hd__fill_2
XFILLER_37_127 VGND VGND VPWR VPWR sky130_fd_sc_hd__decap_3
XFILLER_65_447 VGND VGND VPWR VPWR sky130_fd_sc_hd__fill_1
XFILLER_77_296 VGND VGND VPWR VPWR sky130_fd_sc_hd__fill_2
XFILLER_53_609 VGND VGND VPWR VPWR sky130_fd_sc_hd__decap_3
XFILLER_65_458 VGND VGND VPWR VPWR sky130_fd_sc_hd__decap_3
XFILLER_92_244 VGND VGND VPWR VPWR sky130_fd_sc_hd__fill_1
XTAP_TAPCELL_ROW_88_1359 VGND VPWR sky130_fd_sc_hd__tapvpwrvgnd_1
XFILLER_18_363 VGND VGND VPWR VPWR sky130_fd_sc_hd__fill_1
XFILLER_18_374 VGND VGND VPWR VPWR sky130_fd_sc_hd__decap_3
XFILLER_33_311 VGND VGND VPWR VPWR sky130_fd_sc_hd__decap_3
XFILLER_46_672 VGND VGND VPWR VPWR sky130_fd_sc_hd__decap_3
XFILLER_61_620 VGND VGND VPWR VPWR sky130_fd_sc_hd__decap_3
XFILLER_61_653 VGND VGND VPWR VPWR sky130_fd_sc_hd__decap_3
XFILLER_73_491 VGND VGND VPWR VPWR sky130_fd_sc_hd__decap_3
X_4830_ _4646_/Y _4827_/A _4829_/Y VGND VGND VPWR VPWR _4830_/X sky130_fd_sc_hd__o21a_2
XFILLER_60_141 VGND VGND VPWR VPWR sky130_fd_sc_hd__decap_3
XFILLER_61_697 VGND VGND VPWR VPWR sky130_fd_sc_hd__decap_3
XFILLER_33_399 VGND VGND VPWR VPWR sky130_fd_sc_hd__fill_1
X_4761_ _4762_/B _4761_/B _4761_/C VGND VGND VPWR VPWR _4761_/Y sky130_fd_sc_hd__nand3_2
XFILLER_119_405 VGND VGND VPWR VPWR sky130_fd_sc_hd__decap_3
X_6500_ _6598_/A VGND VGND VPWR VPWR _6500_/Y sky130_fd_sc_hd__inv_2
X_4692_ _7006_/Q _4749_/B VGND VGND VPWR VPWR _4750_/B sky130_fd_sc_hd__and2_2
X_3712_ _3746_/B VGND VGND VPWR VPWR _3741_/B sky130_fd_sc_hd__inv_2
XFILLER_119_438 VGND VGND VPWR VPWR sky130_fd_sc_hd__fill_2
XFILLER_119_449 VGND VGND VPWR VPWR sky130_fd_sc_hd__decap_3
X_6431_ _6630_/A VGND VGND VPWR VPWR _6431_/Y sky130_fd_sc_hd__inv_2
X_6362_ _6554_/A VGND VGND VPWR VPWR _6362_/Y sky130_fd_sc_hd__inv_2
XTAP_TAPCELL_ROW_99_1499 VGND VPWR sky130_fd_sc_hd__tapvpwrvgnd_1
XFILLER_115_611 VGND VGND VPWR VPWR sky130_fd_sc_hd__decap_3
XFILLER_115_644 VGND VGND VPWR VPWR sky130_fd_sc_hd__decap_3
X_3574_ _7348_/Q _4285_/B1 _3573_/X _3556_/A VGND VGND VPWR VPWR _3574_/X sky130_fd_sc_hd__a211o_2
X_6293_ _6637_/A VGND VGND VPWR VPWR _6293_/Y sky130_fd_sc_hd__inv_2
XFILLER_115_688 VGND VGND VPWR VPWR sky130_fd_sc_hd__decap_3
X_5175_ _5175_/A _5207_/B VGND VGND VPWR VPWR _7240_/D sky130_fd_sc_hd__and2_2
XTAP_TAPCELL_ROW_110_1633 VGND VPWR sky130_fd_sc_hd__tapvpwrvgnd_1
XFILLER_29_606 VGND VGND VPWR VPWR sky130_fd_sc_hd__decap_3
XFILLER_29_617 VGND VGND VPWR VPWR sky130_fd_sc_hd__decap_3
XFILLER_68_241 VGND VGND VPWR VPWR sky130_fd_sc_hd__decap_3
XFILLER_84_701 VGND VGND VPWR VPWR sky130_fd_sc_hd__decap_3
X_4126_ _4126_/A _4125_/X VGND VGND VPWR VPWR _4890_/B sky130_fd_sc_hd__or2b_2
XFILLER_110_371 VGND VGND VPWR VPWR sky130_fd_sc_hd__fill_1
XFILLER_56_436 VGND VGND VPWR VPWR sky130_fd_sc_hd__decap_3
XFILLER_83_211 VGND VGND VPWR VPWR sky130_fd_sc_hd__decap_3
XFILLER_37_650 VGND VGND VPWR VPWR sky130_fd_sc_hd__decap_3
XFILLER_45_28 VGND VGND VPWR VPWR sky130_fd_sc_hd__decap_3
XFILLER_83_244 VGND VGND VPWR VPWR sky130_fd_sc_hd__decap_3
XFILLER_83_266 VGND VGND VPWR VPWR sky130_fd_sc_hd__decap_3
X_4057_ _7308_/Q _4488_/S _4181_/B1 _7372_/Q _4429_/C1 VGND VGND VPWR VPWR _4057_/X
+ sky130_fd_sc_hd__a221o_2
XFILLER_37_694 VGND VGND VPWR VPWR sky130_fd_sc_hd__decap_3
XFILLER_64_480 VGND VGND VPWR VPWR sky130_fd_sc_hd__decap_3
XFILLER_24_344 VGND VGND VPWR VPWR sky130_fd_sc_hd__decap_3
XFILLER_36_182 VGND VGND VPWR VPWR sky130_fd_sc_hd__fill_1
XFILLER_52_631 VGND VGND VPWR VPWR sky130_fd_sc_hd__decap_3
XFILLER_24_355 VGND VGND VPWR VPWR sky130_fd_sc_hd__decap_3
XFILLER_24_377 VGND VGND VPWR VPWR sky130_fd_sc_hd__decap_3
XFILLER_51_152 VGND VGND VPWR VPWR sky130_fd_sc_hd__fill_1
XFILLER_52_675 VGND VGND VPWR VPWR sky130_fd_sc_hd__decap_3
XFILLER_12_539 VGND VGND VPWR VPWR sky130_fd_sc_hd__decap_3
XFILLER_61_49 VGND VGND VPWR VPWR sky130_fd_sc_hd__decap_3
X_4959_ _6993_/Q _4958_/Y _6994_/Q VGND VGND VPWR VPWR _4960_/C sky130_fd_sc_hd__a21oi_2
XTAP_TAPCELL_ROW_22_534 VGND VPWR sky130_fd_sc_hd__tapvpwrvgnd_1
XFILLER_20_583 VGND VGND VPWR VPWR sky130_fd_sc_hd__decap_3
X_6629_ _6630_/A VGND VGND VPWR VPWR _6629_/Y sky130_fd_sc_hd__inv_2
XTAP_TAPCELL_ROW_50_887 VGND VPWR sky130_fd_sc_hd__tapvpwrvgnd_1
XFILLER_106_622 VGND VGND VPWR VPWR sky130_fd_sc_hd__decap_3
XFILLER_118_471 VGND VGND VPWR VPWR sky130_fd_sc_hd__decap_3
XFILLER_105_132 VGND VGND VPWR VPWR sky130_fd_sc_hd__decap_3
XFILLER_106_666 VGND VGND VPWR VPWR sky130_fd_sc_hd__decap_3
XFILLER_105_165 VGND VGND VPWR VPWR sky130_fd_sc_hd__decap_3
XFILLER_105_187 VGND VGND VPWR VPWR sky130_fd_sc_hd__decap_3
XFILLER_106_699 VGND VGND VPWR VPWR sky130_fd_sc_hd__fill_1
XFILLER_79_517 VGND VGND VPWR VPWR sky130_fd_sc_hd__decap_3
XFILLER_86_24 VGND VGND VPWR VPWR sky130_fd_sc_hd__decap_3
XFILLER_86_35 VGND VGND VPWR VPWR sky130_fd_sc_hd__decap_3
XFILLER_19_40 VGND VGND VPWR VPWR sky130_fd_sc_hd__decap_3
XFILLER_75_712 VGND VGND VPWR VPWR sky130_fd_sc_hd__fill_2
XFILLER_86_79 VGND VGND VPWR VPWR sky130_fd_sc_hd__decap_3
XFILLER_87_561 VGND VGND VPWR VPWR sky130_fd_sc_hd__decap_3
XFILLER_101_393 VGND VGND VPWR VPWR sky130_fd_sc_hd__decap_3
XFILLER_19_116 VGND VGND VPWR VPWR sky130_fd_sc_hd__decap_3
XFILLER_74_200 VGND VGND VPWR VPWR sky130_fd_sc_hd__decap_3
XFILLER_74_222 VGND VGND VPWR VPWR sky130_fd_sc_hd__decap_3
XFILLER_19_95 VGND VGND VPWR VPWR sky130_fd_sc_hd__fill_1
XFILLER_35_609 VGND VGND VPWR VPWR sky130_fd_sc_hd__decap_3
XFILLER_74_244 VGND VGND VPWR VPWR sky130_fd_sc_hd__decap_3
XFILLER_90_704 VGND VGND VPWR VPWR sky130_fd_sc_hd__decap_3
XFILLER_15_311 VGND VGND VPWR VPWR sky130_fd_sc_hd__decap_3
XFILLER_28_672 VGND VGND VPWR VPWR sky130_fd_sc_hd__decap_3
XFILLER_43_620 VGND VGND VPWR VPWR sky130_fd_sc_hd__decap_3
XFILLER_62_439 VGND VGND VPWR VPWR sky130_fd_sc_hd__decap_3
XTAP_TAPCELL_ROW_58_987 VGND VPWR sky130_fd_sc_hd__tapvpwrvgnd_1
XTAP_TAPCELL_ROW_2_281 VGND VPWR sky130_fd_sc_hd__tapvpwrvgnd_1
XFILLER_43_653 VGND VGND VPWR VPWR sky130_fd_sc_hd__decap_3
XFILLER_42_141 VGND VGND VPWR VPWR sky130_fd_sc_hd__decap_3
XFILLER_42_152 VGND VGND VPWR VPWR sky130_fd_sc_hd__decap_3
XFILLER_15_399 VGND VGND VPWR VPWR sky130_fd_sc_hd__decap_3
XFILLER_30_336 VGND VGND VPWR VPWR sky130_fd_sc_hd__decap_3
XFILLER_43_697 VGND VGND VPWR VPWR sky130_fd_sc_hd__decap_3
XFILLER_70_494 VGND VGND VPWR VPWR sky130_fd_sc_hd__fill_2
XFILLER_11_550 VGND VGND VPWR VPWR sky130_fd_sc_hd__decap_3
XFILLER_11_561 VGND VGND VPWR VPWR sky130_fd_sc_hd__decap_3
XFILLER_11_594 VGND VGND VPWR VPWR sky130_fd_sc_hd__decap_3
XFILLER_51_60 VGND VGND VPWR VPWR sky130_fd_sc_hd__fill_2
XFILLER_7_554 VGND VGND VPWR VPWR sky130_fd_sc_hd__decap_3
XFILLER_7_576 VGND VGND VPWR VPWR sky130_fd_sc_hd__decap_3
XFILLER_112_625 VGND VGND VPWR VPWR sky130_fd_sc_hd__decap_3
XFILLER_111_113 VGND VGND VPWR VPWR sky130_fd_sc_hd__decap_3
XFILLER_112_669 VGND VGND VPWR VPWR sky130_fd_sc_hd__decap_3
XFILLER_111_146 VGND VGND VPWR VPWR sky130_fd_sc_hd__fill_2
XFILLER_66_701 VGND VGND VPWR VPWR sky130_fd_sc_hd__decap_3
XFILLER_97_369 VGND VGND VPWR VPWR sky130_fd_sc_hd__fill_2
XFILLER_18_3 VGND VGND VPWR VPWR sky130_fd_sc_hd__fill_1
XFILLER_38_447 VGND VGND VPWR VPWR sky130_fd_sc_hd__decap_3
XFILLER_19_650 VGND VGND VPWR VPWR sky130_fd_sc_hd__decap_3
XFILLER_65_255 VGND VGND VPWR VPWR sky130_fd_sc_hd__decap_3
XFILLER_93_553 VGND VGND VPWR VPWR sky130_fd_sc_hd__decap_3
X_6980_ _6983_/CLK _6980_/D _6260_/Y VGND VGND VPWR VPWR _6980_/Q sky130_fd_sc_hd__dfrtp_2
XFILLER_19_694 VGND VGND VPWR VPWR sky130_fd_sc_hd__decap_3
XFILLER_25_108 VGND VGND VPWR VPWR sky130_fd_sc_hd__decap_3
XFILLER_25_119 VGND VGND VPWR VPWR sky130_fd_sc_hd__decap_3
XFILLER_53_417 VGND VGND VPWR VPWR sky130_fd_sc_hd__decap_3
XFILLER_53_439 VGND VGND VPWR VPWR sky130_fd_sc_hd__decap_3
XFILLER_65_288 VGND VGND VPWR VPWR sky130_fd_sc_hd__decap_3
XFILLER_80_203 VGND VGND VPWR VPWR sky130_fd_sc_hd__decap_3
XFILLER_80_225 VGND VGND VPWR VPWR sky130_fd_sc_hd__decap_3
XFILLER_18_182 VGND VGND VPWR VPWR sky130_fd_sc_hd__decap_3
XFILLER_34_631 VGND VGND VPWR VPWR sky130_fd_sc_hd__decap_3
XFILLER_46_480 VGND VGND VPWR VPWR sky130_fd_sc_hd__decap_3
XFILLER_34_675 VGND VGND VPWR VPWR sky130_fd_sc_hd__decap_3
XFILLER_61_483 VGND VGND VPWR VPWR sky130_fd_sc_hd__decap_3
X_4813_ _4813_/A _4813_/B VGND VGND VPWR VPWR _4813_/Y sky130_fd_sc_hd__nand2_2
X_4744_ _4938_/A _4744_/B VGND VGND VPWR VPWR _4744_/Y sky130_fd_sc_hd__nor2_2
XFILLER_119_213 VGND VGND VPWR VPWR sky130_fd_sc_hd__decap_3
XFILLER_119_268 VGND VGND VPWR VPWR sky130_fd_sc_hd__decap_3
X_4675_ _3991_/A _3469_/B _3564_/X _3449_/A _6984_/Q VGND VGND VPWR VPWR _5067_/B
+ sky130_fd_sc_hd__o2111a_2
X_7394_ _7403_/CLK _7394_/D _6674_/Y VGND VGND VPWR VPWR _7394_/Q sky130_fd_sc_hd__dfrtp_2
X_6414_ _6641_/A VGND VGND VPWR VPWR _6414_/Y sky130_fd_sc_hd__inv_2
X_3626_ _3616_/Y _3617_/X _3625_/X VGND VGND VPWR VPWR _3733_/C sky130_fd_sc_hd__a21oi_4
X_6345_ _6672_/A VGND VGND VPWR VPWR _6345_/Y sky130_fd_sc_hd__inv_2
X_3557_ _7221_/Q _3377_/X _5229_/C _7125_/Q _3556_/X VGND VGND VPWR VPWR _3557_/X
+ sky130_fd_sc_hd__a221o_2
XFILLER_115_463 VGND VGND VPWR VPWR sky130_fd_sc_hd__decap_3
X_6276_ _6483_/A VGND VGND VPWR VPWR _6276_/Y sky130_fd_sc_hd__inv_2
XFILLER_102_124 VGND VGND VPWR VPWR sky130_fd_sc_hd__decap_3
XFILLER_103_647 VGND VGND VPWR VPWR sky130_fd_sc_hd__decap_3
XFILLER_88_358 VGND VGND VPWR VPWR sky130_fd_sc_hd__decap_3
X_5227_ _7215_/Q _5211_/B _5655_/B VGND VGND VPWR VPWR _7215_/D sky130_fd_sc_hd__a21o_2
X_3488_ _7279_/Q _4534_/S VGND VGND VPWR VPWR _3488_/X sky130_fd_sc_hd__and2_2
XFILLER_102_168 VGND VGND VPWR VPWR sky130_fd_sc_hd__decap_3
XFILLER_57_712 VGND VGND VPWR VPWR sky130_fd_sc_hd__fill_2
XFILLER_111_691 VGND VGND VPWR VPWR sky130_fd_sc_hd__decap_3
XFILLER_29_414 VGND VGND VPWR VPWR sky130_fd_sc_hd__decap_3
XFILLER_96_380 VGND VGND VPWR VPWR sky130_fd_sc_hd__decap_3
XFILLER_72_704 VGND VGND VPWR VPWR sky130_fd_sc_hd__decap_3
X_5089_ _4764_/B _4315_/A _5086_/A _5101_/A _5088_/X VGND VGND VPWR VPWR _5089_/Y
+ sky130_fd_sc_hd__o221ai_2
X_4109_ _4376_/A _4141_/A _4141_/B _4142_/C VGND VGND VPWR VPWR _4109_/X sky130_fd_sc_hd__o31a_2
XFILLER_56_299 VGND VGND VPWR VPWR sky130_fd_sc_hd__decap_3
XFILLER_71_214 VGND VGND VPWR VPWR sky130_fd_sc_hd__decap_3
XFILLER_84_597 VGND VGND VPWR VPWR sky130_fd_sc_hd__fill_1
XFILLER_112_44 VGND VGND VPWR VPWR sky130_fd_sc_hd__decap_3
XFILLER_112_77 VGND VGND VPWR VPWR sky130_fd_sc_hd__decap_3
XFILLER_25_620 VGND VGND VPWR VPWR sky130_fd_sc_hd__decap_3
XFILLER_25_653 VGND VGND VPWR VPWR sky130_fd_sc_hd__decap_3
XFILLER_37_491 VGND VGND VPWR VPWR sky130_fd_sc_hd__decap_3
XFILLER_71_225 VGND VGND VPWR VPWR sky130_fd_sc_hd__decap_3
XTAP_TAPCELL_ROW_55_946 VGND VPWR sky130_fd_sc_hd__tapvpwrvgnd_1
XFILLER_24_141 VGND VGND VPWR VPWR sky130_fd_sc_hd__decap_3
XFILLER_40_601 VGND VGND VPWR VPWR sky130_fd_sc_hd__decap_3
XFILLER_52_461 VGND VGND VPWR VPWR sky130_fd_sc_hd__decap_3
XFILLER_12_336 VGND VGND VPWR VPWR sky130_fd_sc_hd__decap_3
XFILLER_24_174 VGND VGND VPWR VPWR sky130_fd_sc_hd__decap_3
XFILLER_25_697 VGND VGND VPWR VPWR sky130_fd_sc_hd__decap_3
XFILLER_40_634 VGND VGND VPWR VPWR sky130_fd_sc_hd__decap_3
XFILLER_40_645 VGND VGND VPWR VPWR sky130_fd_sc_hd__decap_3
XTAP_TAPCELL_ROW_35_692 VGND VPWR sky130_fd_sc_hd__tapvpwrvgnd_1
XFILLER_40_678 VGND VGND VPWR VPWR sky130_fd_sc_hd__decap_3
XFILLER_8_318 VGND VGND VPWR VPWR sky130_fd_sc_hd__decap_3
XFILLER_21_52 VGND VGND VPWR VPWR sky130_fd_sc_hd__decap_3
XFILLER_21_63 VGND VGND VPWR VPWR sky130_fd_sc_hd__decap_3
XFILLER_4_524 VGND VGND VPWR VPWR sky130_fd_sc_hd__decap_3
XFILLER_106_430 VGND VGND VPWR VPWR sky130_fd_sc_hd__decap_3
XFILLER_4_557 VGND VGND VPWR VPWR sky130_fd_sc_hd__decap_3
XFILLER_106_485 VGND VGND VPWR VPWR sky130_fd_sc_hd__decap_3
XFILLER_79_303 VGND VGND VPWR VPWR sky130_fd_sc_hd__decap_3
XTAP_TAPCELL_ROW_7_340 VGND VPWR sky130_fd_sc_hd__tapvpwrvgnd_1
XFILLER_48_701 VGND VGND VPWR VPWR sky130_fd_sc_hd__decap_3
XFILLER_79_369 VGND VGND VPWR VPWR sky130_fd_sc_hd__decap_3
XTAP_TAPCELL_ROW_7_351 VGND VPWR sky130_fd_sc_hd__tapvpwrvgnd_1
XFILLER_47_211 VGND VGND VPWR VPWR sky130_fd_sc_hd__decap_3
XFILLER_75_531 VGND VGND VPWR VPWR sky130_fd_sc_hd__decap_3
XFILLER_101_190 VGND VGND VPWR VPWR sky130_fd_sc_hd__decap_3
XFILLER_62_214 VGND VGND VPWR VPWR sky130_fd_sc_hd__fill_2
XTAP_TAPCELL_ROW_85_1318 VGND VPWR sky130_fd_sc_hd__tapvpwrvgnd_1
XFILLER_16_631 VGND VGND VPWR VPWR sky130_fd_sc_hd__decap_3
XFILLER_28_480 VGND VGND VPWR VPWR sky130_fd_sc_hd__decap_3
XFILLER_16_675 VGND VGND VPWR VPWR sky130_fd_sc_hd__decap_3
XFILLER_31_601 VGND VGND VPWR VPWR sky130_fd_sc_hd__decap_3
XFILLER_43_461 VGND VGND VPWR VPWR sky130_fd_sc_hd__decap_3
XFILLER_50_409 VGND VGND VPWR VPWR sky130_fd_sc_hd__decap_3
XFILLER_15_196 VGND VGND VPWR VPWR sky130_fd_sc_hd__decap_3
XFILLER_31_623 VGND VGND VPWR VPWR sky130_fd_sc_hd__decap_3
XFILLER_30_155 VGND VGND VPWR VPWR sky130_fd_sc_hd__decap_3
XFILLER_31_656 VGND VGND VPWR VPWR sky130_fd_sc_hd__decap_3
XFILLER_30_177 VGND VGND VPWR VPWR sky130_fd_sc_hd__decap_3
XFILLER_117_706 VGND VGND VPWR VPWR sky130_fd_sc_hd__decap_3
XFILLER_7_32 VGND VGND VPWR VPWR sky130_fd_sc_hd__decap_3
XFILLER_7_340 VGND VGND VPWR VPWR sky130_fd_sc_hd__decap_3
XFILLER_7_54 VGND VGND VPWR VPWR sky130_fd_sc_hd__fill_2
XFILLER_7_373 VGND VGND VPWR VPWR sky130_fd_sc_hd__decap_3
X_4460_ _4460_/A _4460_/B VGND VGND VPWR VPWR _4460_/Y sky130_fd_sc_hd__nand2_2
XTAP_TAPCELL_ROW_96_1458 VGND VPWR sky130_fd_sc_hd__tapvpwrvgnd_1
XFILLER_109_290 VGND VGND VPWR VPWR sky130_fd_sc_hd__decap_3
XFILLER_7_98 VGND VGND VPWR VPWR sky130_fd_sc_hd__decap_3
X_4391_ _7401_/Q _4437_/B1 _4436_/B1 _7177_/Q _4390_/X VGND VGND VPWR VPWR _4391_/X
+ sky130_fd_sc_hd__a221o_2
XFILLER_97_100 VGND VGND VPWR VPWR sky130_fd_sc_hd__decap_3
X_3342_ _3561_/B _6982_/Q VGND VGND VPWR VPWR _5118_/D sky130_fd_sc_hd__nand2b_4
XFILLER_112_444 VGND VGND VPWR VPWR sky130_fd_sc_hd__decap_3
XFILLER_98_645 VGND VGND VPWR VPWR sky130_fd_sc_hd__decap_3
XFILLER_100_617 VGND VGND VPWR VPWR sky130_fd_sc_hd__decap_3
XFILLER_112_477 VGND VGND VPWR VPWR sky130_fd_sc_hd__decap_3
XFILLER_85_317 VGND VGND VPWR VPWR sky130_fd_sc_hd__decap_3
XFILLER_98_678 VGND VGND VPWR VPWR sky130_fd_sc_hd__decap_3
XFILLER_112_499 VGND VGND VPWR VPWR sky130_fd_sc_hd__decap_3
XFILLER_38_200 VGND VGND VPWR VPWR sky130_fd_sc_hd__decap_3
XFILLER_39_712 VGND VGND VPWR VPWR sky130_fd_sc_hd__fill_2
XFILLER_66_520 VGND VGND VPWR VPWR sky130_fd_sc_hd__decap_3
XFILLER_97_177 VGND VGND VPWR VPWR sky130_fd_sc_hd__decap_3
Xhold1007 _6706_/Q VGND VGND VPWR VPWR _5712_/A1 sky130_fd_sc_hd__dlygate4sd3_1
Xhold1018 _6687_/Q VGND VGND VPWR VPWR _5674_/A1 sky130_fd_sc_hd__dlygate4sd3_1
Xhold1029 _7050_/Q VGND VGND VPWR VPWR _5567_/A1 sky130_fd_sc_hd__dlygate4sd3_1
X_5012_ _5012_/A0 _5011_/X _5028_/S VGND VGND VPWR VPWR _7261_/D sky130_fd_sc_hd__mux2_2
XFILLER_38_244 VGND VGND VPWR VPWR sky130_fd_sc_hd__decap_3
XFILLER_54_704 VGND VGND VPWR VPWR sky130_fd_sc_hd__decap_3
XFILLER_66_542 VGND VGND VPWR VPWR sky130_fd_sc_hd__decap_3
XFILLER_53_203 VGND VGND VPWR VPWR sky130_fd_sc_hd__decap_3
XFILLER_81_501 VGND VGND VPWR VPWR sky130_fd_sc_hd__decap_3
XFILLER_19_491 VGND VGND VPWR VPWR sky130_fd_sc_hd__fill_1
XFILLER_53_225 VGND VGND VPWR VPWR sky130_fd_sc_hd__decap_3
X_6963_ clkload6/A _6963_/D VGND VGND VPWR VPWR _6963_/Q sky130_fd_sc_hd__dfxtp_2
XFILLER_22_601 VGND VGND VPWR VPWR sky130_fd_sc_hd__decap_3
XFILLER_53_258 VGND VGND VPWR VPWR sky130_fd_sc_hd__decap_3
X_6894_ _6942_/CLK _6894_/D VGND VGND VPWR VPWR _6894_/Q sky130_fd_sc_hd__dfxtp_2
XTAP_TAPCELL_ROW_52_905 VGND VPWR sky130_fd_sc_hd__tapvpwrvgnd_1
XTAP_TAPCELL_ROW_105_1565 VGND VPWR sky130_fd_sc_hd__tapvpwrvgnd_1
XFILLER_21_100 VGND VGND VPWR VPWR sky130_fd_sc_hd__decap_3
XFILLER_22_634 VGND VGND VPWR VPWR sky130_fd_sc_hd__decap_3
XFILLER_34_483 VGND VGND VPWR VPWR sky130_fd_sc_hd__decap_3
XTAP_TAPCELL_ROW_105_1576 VGND VPWR sky130_fd_sc_hd__tapvpwrvgnd_1
XFILLER_21_122 VGND VGND VPWR VPWR sky130_fd_sc_hd__decap_3
XFILLER_22_645 VGND VGND VPWR VPWR sky130_fd_sc_hd__decap_3
XFILLER_22_678 VGND VGND VPWR VPWR sky130_fd_sc_hd__decap_3
XFILLER_61_291 VGND VGND VPWR VPWR sky130_fd_sc_hd__decap_3
XTAP_TAPCELL_ROW_32_662 VGND VPWR sky130_fd_sc_hd__tapvpwrvgnd_1
X_4727_ _7007_/Q _4750_/B _4777_/A VGND VGND VPWR VPWR _4728_/B sky130_fd_sc_hd__o21a_2
X_4658_ _4658_/A _4658_/B VGND VGND VPWR VPWR _4658_/Y sky130_fd_sc_hd__nand2_2
XFILLER_107_249 VGND VGND VPWR VPWR sky130_fd_sc_hd__decap_3
Xhold830 _6975_/Q VGND VGND VPWR VPWR _6975_/D sky130_fd_sc_hd__dlygate4sd3_1
X_3609_ _5071_/A _5114_/A VGND VGND VPWR VPWR _3610_/B sky130_fd_sc_hd__nand2_2
XFILLER_1_505 VGND VGND VPWR VPWR sky130_fd_sc_hd__decap_3
XFILLER_88_100 VGND VGND VPWR VPWR sky130_fd_sc_hd__decap_3
XFILLER_89_601 VGND VGND VPWR VPWR sky130_fd_sc_hd__decap_3
XFILLER_89_623 VGND VGND VPWR VPWR sky130_fd_sc_hd__decap_3
X_7377_ _7388_/CLK _7377_/D _6657_/Y VGND VGND VPWR VPWR _7377_/Q sky130_fd_sc_hd__dfrtp_2
Xhold841 _6757_/Q VGND VGND VPWR VPWR _6757_/D sky130_fd_sc_hd__dlygate4sd3_1
Xhold852 _6771_/Q VGND VGND VPWR VPWR _6771_/D sky130_fd_sc_hd__dlygate4sd3_1
Xhold863 _6888_/Q VGND VGND VPWR VPWR _6888_/D sky130_fd_sc_hd__dlygate4sd3_1
X_4589_ _4589_/A _4595_/B VGND VGND VPWR VPWR _7286_/D sky130_fd_sc_hd__and2_2
XFILLER_107_44 VGND VGND VPWR VPWR sky130_fd_sc_hd__decap_3
XFILLER_107_66 VGND VGND VPWR VPWR sky130_fd_sc_hd__decap_3
XFILLER_115_293 VGND VGND VPWR VPWR sky130_fd_sc_hd__fill_1
XFILLER_1_538 VGND VGND VPWR VPWR sky130_fd_sc_hd__decap_3
XFILLER_89_656 VGND VGND VPWR VPWR sky130_fd_sc_hd__decap_3
Xhold874 _6793_/Q VGND VGND VPWR VPWR _6793_/D sky130_fd_sc_hd__dlygate4sd3_1
Xhold885 _6790_/Q VGND VGND VPWR VPWR _6790_/D sky130_fd_sc_hd__dlygate4sd3_1
Xhold896 _6941_/Q VGND VGND VPWR VPWR _6941_/D sky130_fd_sc_hd__dlygate4sd3_1
X_6328_ _6550_/A VGND VGND VPWR VPWR _6328_/Y sky130_fd_sc_hd__inv_2
XFILLER_103_444 VGND VGND VPWR VPWR sky130_fd_sc_hd__decap_3
XFILLER_103_455 VGND VGND VPWR VPWR sky130_fd_sc_hd__decap_3
XFILLER_107_99 VGND VGND VPWR VPWR sky130_fd_sc_hd__decap_3
XFILLER_88_144 VGND VGND VPWR VPWR sky130_fd_sc_hd__decap_3
X_6259_ _6677_/A VGND VGND VPWR VPWR _6259_/Y sky130_fd_sc_hd__inv_2
XFILLER_29_211 VGND VGND VPWR VPWR sky130_fd_sc_hd__decap_3
XFILLER_88_177 VGND VGND VPWR VPWR sky130_fd_sc_hd__decap_3
XTAP_TAPCELL_ROW_4_310 VGND VPWR sky130_fd_sc_hd__tapvpwrvgnd_1
XFILLER_57_542 VGND VGND VPWR VPWR sky130_fd_sc_hd__decap_3
XFILLER_91_309 VGND VGND VPWR VPWR sky130_fd_sc_hd__decap_3
XFILLER_29_255 VGND VGND VPWR VPWR sky130_fd_sc_hd__decap_3
XFILLER_44_203 VGND VGND VPWR VPWR sky130_fd_sc_hd__decap_3
XFILLER_57_586 VGND VGND VPWR VPWR sky130_fd_sc_hd__decap_3
XFILLER_72_501 VGND VGND VPWR VPWR sky130_fd_sc_hd__decap_3
XFILLER_84_350 VGND VGND VPWR VPWR sky130_fd_sc_hd__decap_3
XFILLER_72_545 VGND VGND VPWR VPWR sky130_fd_sc_hd__fill_2
XFILLER_83_47 VGND VGND VPWR VPWR sky130_fd_sc_hd__fill_1
XFILLER_83_69 VGND VGND VPWR VPWR sky130_fd_sc_hd__decap_3
XFILLER_16_52 VGND VGND VPWR VPWR sky130_fd_sc_hd__fill_2
XFILLER_32_409 VGND VGND VPWR VPWR sky130_fd_sc_hd__decap_3
XFILLER_60_707 VGND VGND VPWR VPWR sky130_fd_sc_hd__decap_3
XFILLER_13_612 VGND VGND VPWR VPWR sky130_fd_sc_hd__decap_3
XFILLER_13_623 VGND VGND VPWR VPWR sky130_fd_sc_hd__decap_3
XPHY_EDGE_ROW_11_Right_11 VGND VGND VPWR VPWR sky130_fd_sc_hd__decap_3
XFILLER_13_656 VGND VGND VPWR VPWR sky130_fd_sc_hd__decap_3
XFILLER_52_291 VGND VGND VPWR VPWR sky130_fd_sc_hd__decap_3
XTAP_TAPCELL_ROW_80_1259 VGND VPWR sky130_fd_sc_hd__tapvpwrvgnd_1
XFILLER_12_177 VGND VGND VPWR VPWR sky130_fd_sc_hd__fill_2
XFILLER_40_475 VGND VGND VPWR VPWR sky130_fd_sc_hd__fill_1
XFILLER_40_486 VGND VGND VPWR VPWR sky130_fd_sc_hd__decap_3
XFILLER_9_638 VGND VGND VPWR VPWR sky130_fd_sc_hd__decap_3
XFILLER_8_137 VGND VGND VPWR VPWR sky130_fd_sc_hd__decap_3
XFILLER_8_159 VGND VGND VPWR VPWR sky130_fd_sc_hd__decap_3
XTAP_TAPCELL_ROW_10_389 VGND VPWR sky130_fd_sc_hd__tapvpwrvgnd_1
XTAP_TAPCELL_ROW_10_378 VGND VPWR sky130_fd_sc_hd__tapvpwrvgnd_1
XFILLER_99_409 VGND VGND VPWR VPWR sky130_fd_sc_hd__decap_3
XFILLER_4_376 VGND VGND VPWR VPWR sky130_fd_sc_hd__decap_3
XFILLER_106_271 VGND VGND VPWR VPWR sky130_fd_sc_hd__decap_3
XFILLER_79_122 VGND VGND VPWR VPWR sky130_fd_sc_hd__decap_3
XPHY_EDGE_ROW_20_Right_20 VGND VGND VPWR VPWR sky130_fd_sc_hd__decap_3
XFILLER_95_604 VGND VGND VPWR VPWR sky130_fd_sc_hd__decap_3
XFILLER_0_582 VGND VGND VPWR VPWR sky130_fd_sc_hd__decap_3
XFILLER_94_103 VGND VGND VPWR VPWR sky130_fd_sc_hd__decap_3
XFILLER_95_626 VGND VGND VPWR VPWR sky130_fd_sc_hd__decap_3
XTAP_TAPCELL_ROW_91_1399 VGND VPWR sky130_fd_sc_hd__tapvpwrvgnd_1
XFILLER_48_542 VGND VGND VPWR VPWR sky130_fd_sc_hd__fill_2
XFILLER_94_136 VGND VGND VPWR VPWR sky130_fd_sc_hd__decap_3
XFILLER_95_659 VGND VGND VPWR VPWR sky130_fd_sc_hd__decap_3
XFILLER_36_704 VGND VGND VPWR VPWR sky130_fd_sc_hd__decap_3
XFILLER_48_564 VGND VGND VPWR VPWR sky130_fd_sc_hd__decap_3
XFILLER_75_350 VGND VGND VPWR VPWR sky130_fd_sc_hd__decap_3
XFILLER_35_225 VGND VGND VPWR VPWR sky130_fd_sc_hd__decap_3
XFILLER_63_523 VGND VGND VPWR VPWR sky130_fd_sc_hd__decap_3
XFILLER_63_556 VGND VGND VPWR VPWR sky130_fd_sc_hd__fill_1
Xplace501 _3332_/B VGND VGND VPWR VPWR _3318_/B sky130_fd_sc_hd__buf_2
Xplace512 _6979_/Q VGND VGND VPWR VPWR _5667_/A sky130_fd_sc_hd__buf_4
XFILLER_50_206 VGND VGND VPWR VPWR sky130_fd_sc_hd__fill_2
Xplace523 _6686_/A VGND VGND VPWR VPWR _6483_/A sky130_fd_sc_hd__buf_2
Xplace534 _6645_/A VGND VGND VPWR VPWR _6680_/A sky130_fd_sc_hd__buf_2
Xplace545 _6642_/A VGND VGND VPWR VPWR _6641_/A sky130_fd_sc_hd__buf_2
Xplace556 _6640_/A VGND VGND VPWR VPWR _6631_/A sky130_fd_sc_hd__buf_2
X_3960_ _7360_/Q _4503_/A0 _3975_/S VGND VGND VPWR VPWR _7360_/D sky130_fd_sc_hd__mux2_2
XFILLER_50_239 VGND VGND VPWR VPWR sky130_fd_sc_hd__fill_1
XFILLER_90_386 VGND VGND VPWR VPWR sky130_fd_sc_hd__fill_1
Xplace567 _6627_/A VGND VGND VPWR VPWR _6630_/A sky130_fd_sc_hd__buf_2
XTAP_TAPCELL_ROW_18_489 VGND VPWR sky130_fd_sc_hd__tapvpwrvgnd_1
XTAP_TAPCELL_ROW_18_478 VGND VPWR sky130_fd_sc_hd__tapvpwrvgnd_1
XFILLER_31_431 VGND VGND VPWR VPWR sky130_fd_sc_hd__fill_2
X_3891_ _6951_/Q _3651_/Y _3665_/X _6957_/Q _3890_/X VGND VGND VPWR VPWR _3891_/X
+ sky130_fd_sc_hd__a221o_2
X_5630_ _5630_/A _5634_/B VGND VGND VPWR VPWR _7013_/D sky130_fd_sc_hd__and2_2
X_5561_ _5561_/A1 _4777_/A _4695_/X VGND VGND VPWR VPWR _7054_/D sky130_fd_sc_hd__o21a_2
XFILLER_117_503 VGND VGND VPWR VPWR sky130_fd_sc_hd__fill_1
XFILLER_117_514 VGND VGND VPWR VPWR sky130_fd_sc_hd__decap_3
XFILLER_8_660 VGND VGND VPWR VPWR sky130_fd_sc_hd__decap_3
X_7300_ _7333_/CLK _7300_/D _6580_/Y VGND VGND VPWR VPWR _7300_/Q sky130_fd_sc_hd__dfrtp_2
XFILLER_105_709 VGND VGND VPWR VPWR sky130_fd_sc_hd__decap_3
XFILLER_8_693 VGND VGND VPWR VPWR sky130_fd_sc_hd__decap_3
X_7231_ _7360_/CLK _7231_/D _6511_/Y VGND VGND VPWR VPWR _7231_/Q sky130_fd_sc_hd__dfrtp_2
XFILLER_104_208 VGND VGND VPWR VPWR sky130_fd_sc_hd__decap_3
X_4443_ _4778_/A _4778_/B _4795_/A _4787_/A _4779_/A VGND VGND VPWR VPWR _4761_/B
+ sky130_fd_sc_hd__a2111o_2
X_7162_ _7354_/CLK _7162_/D _6442_/Y VGND VGND VPWR VPWR _7162_/Q sky130_fd_sc_hd__dfrtp_2
X_4374_ _4371_/Y _4224_/C _4373_/Y VGND VGND VPWR VPWR _4374_/X sky130_fd_sc_hd__o21a_2
XFILLER_58_306 VGND VGND VPWR VPWR sky130_fd_sc_hd__fill_2
XFILLER_98_475 VGND VGND VPWR VPWR sky130_fd_sc_hd__fill_1
X_7093_ _7350_/CLK _7093_/D _6373_/Y VGND VGND VPWR VPWR _7093_/Q sky130_fd_sc_hd__dfrtp_2
X_3325_ _3323_/X _3324_/X _5670_/A VGND VGND VPWR VPWR _3326_/B sky130_fd_sc_hd__a21oi_2
XFILLER_100_414 VGND VGND VPWR VPWR sky130_fd_sc_hd__decap_3
XFILLER_112_274 VGND VGND VPWR VPWR sky130_fd_sc_hd__decap_3
XFILLER_39_520 VGND VGND VPWR VPWR sky130_fd_sc_hd__decap_3
XFILLER_85_125 VGND VGND VPWR VPWR sky130_fd_sc_hd__decap_3
XFILLER_86_626 VGND VGND VPWR VPWR sky130_fd_sc_hd__decap_3
XFILLER_86_648 VGND VGND VPWR VPWR sky130_fd_sc_hd__decap_3
XFILLER_98_486 VGND VGND VPWR VPWR sky130_fd_sc_hd__decap_3
XPHY_EDGE_ROW_13_Left_133 VGND VGND VPWR VPWR sky130_fd_sc_hd__decap_3
XFILLER_100_458 VGND VGND VPWR VPWR sky130_fd_sc_hd__decap_3
XFILLER_85_158 VGND VGND VPWR VPWR sky130_fd_sc_hd__decap_3
XFILLER_26_203 VGND VGND VPWR VPWR sky130_fd_sc_hd__decap_3
XFILLER_85_169 VGND VGND VPWR VPWR sky130_fd_sc_hd__decap_3
XFILLER_94_681 VGND VGND VPWR VPWR sky130_fd_sc_hd__decap_3
XFILLER_54_545 VGND VGND VPWR VPWR sky130_fd_sc_hd__decap_3
XFILLER_81_331 VGND VGND VPWR VPWR sky130_fd_sc_hd__fill_2
XTAP_TAPCELL_ROW_37_721 VGND VPWR sky130_fd_sc_hd__tapvpwrvgnd_1
XFILLER_26_269 VGND VGND VPWR VPWR sky130_fd_sc_hd__decap_3
XFILLER_42_707 VGND VGND VPWR VPWR sky130_fd_sc_hd__decap_3
XFILLER_54_578 VGND VGND VPWR VPWR sky130_fd_sc_hd__decap_3
X_6946_ _6983_/CLK _6946_/D VGND VGND VPWR VPWR _6946_/Q sky130_fd_sc_hd__dfxtp_2
XFILLER_41_228 VGND VGND VPWR VPWR sky130_fd_sc_hd__decap_3
XFILLER_41_239 VGND VGND VPWR VPWR sky130_fd_sc_hd__decap_3
XFILLER_81_386 VGND VGND VPWR VPWR sky130_fd_sc_hd__decap_3
XTAP_TAPCELL_ROW_66_1081 VGND VPWR sky130_fd_sc_hd__tapvpwrvgnd_1
X_6877_ clkload4/A _6877_/D VGND VGND VPWR VPWR _6877_/Q sky130_fd_sc_hd__dfxtp_2
XPHY_EDGE_ROW_22_Left_142 VGND VGND VPWR VPWR sky130_fd_sc_hd__decap_3
XFILLER_10_604 VGND VGND VPWR VPWR sky130_fd_sc_hd__decap_3
XFILLER_22_486 VGND VGND VPWR VPWR sky130_fd_sc_hd__decap_3
XFILLER_10_637 VGND VGND VPWR VPWR sky130_fd_sc_hd__decap_3
XFILLER_10_648 VGND VGND VPWR VPWR sky130_fd_sc_hd__decap_3
XFILLER_108_514 VGND VGND VPWR VPWR sky130_fd_sc_hd__decap_3
XFILLER_6_619 VGND VGND VPWR VPWR sky130_fd_sc_hd__decap_3
XTAP_TAPCELL_ROW_118_1734 VGND VPWR sky130_fd_sc_hd__tapvpwrvgnd_1
XFILLER_118_32 VGND VGND VPWR VPWR sky130_fd_sc_hd__decap_3
XFILLER_118_65 VGND VGND VPWR VPWR sky130_fd_sc_hd__decap_3
XFILLER_1_324 VGND VGND VPWR VPWR sky130_fd_sc_hd__decap_3
XPHY_EDGE_ROW_31_Left_151 VGND VGND VPWR VPWR sky130_fd_sc_hd__decap_3
XFILLER_103_252 VGND VGND VPWR VPWR sky130_fd_sc_hd__decap_3
XFILLER_77_615 VGND VGND VPWR VPWR sky130_fd_sc_hd__fill_1
XFILLER_89_442 VGND VGND VPWR VPWR sky130_fd_sc_hd__decap_3
Xhold682 _6904_/Q VGND VGND VPWR VPWR _6904_/D sky130_fd_sc_hd__dlygate4sd3_1
Xhold693 _6853_/Q VGND VGND VPWR VPWR _6853_/D sky130_fd_sc_hd__dlygate4sd3_1
XFILLER_49_328 VGND VGND VPWR VPWR sky130_fd_sc_hd__decap_3
XFILLER_77_626 VGND VGND VPWR VPWR sky130_fd_sc_hd__decap_3
XFILLER_89_486 VGND VGND VPWR VPWR sky130_fd_sc_hd__decap_3
XFILLER_76_147 VGND VGND VPWR VPWR sky130_fd_sc_hd__fill_1
XFILLER_77_659 VGND VGND VPWR VPWR sky130_fd_sc_hd__decap_3
XFILLER_17_203 VGND VGND VPWR VPWR sky130_fd_sc_hd__decap_3
XFILLER_18_704 VGND VGND VPWR VPWR sky130_fd_sc_hd__decap_3
XFILLER_64_309 VGND VGND VPWR VPWR sky130_fd_sc_hd__decap_3
XFILLER_45_545 VGND VGND VPWR VPWR sky130_fd_sc_hd__fill_1
XFILLER_84_191 VGND VGND VPWR VPWR sky130_fd_sc_hd__decap_3
XFILLER_91_139 VGND VGND VPWR VPWR sky130_fd_sc_hd__decap_3
XFILLER_27_73 VGND VGND VPWR VPWR sky130_fd_sc_hd__decap_3
XFILLER_72_353 VGND VGND VPWR VPWR sky130_fd_sc_hd__fill_2
XFILLER_60_515 VGND VGND VPWR VPWR sky130_fd_sc_hd__decap_3
XFILLER_72_397 VGND VGND VPWR VPWR sky130_fd_sc_hd__decap_3
XPHY_EDGE_ROW_40_Left_160 VGND VGND VPWR VPWR sky130_fd_sc_hd__decap_3
XTAP_TAPCELL_ROW_15_448 VGND VPWR sky130_fd_sc_hd__tapvpwrvgnd_1
XFILLER_13_464 VGND VGND VPWR VPWR sky130_fd_sc_hd__decap_3
XFILLER_9_402 VGND VGND VPWR VPWR sky130_fd_sc_hd__decap_3
XFILLER_40_283 VGND VGND VPWR VPWR sky130_fd_sc_hd__decap_3
XFILLER_9_468 VGND VGND VPWR VPWR sky130_fd_sc_hd__decap_3
XFILLER_71_9 VGND VGND VPWR VPWR sky130_fd_sc_hd__decap_3
XFILLER_5_641 VGND VGND VPWR VPWR sky130_fd_sc_hd__decap_3
XTAP_TAPCELL_ROW_93_1417 VGND VPWR sky130_fd_sc_hd__tapvpwrvgnd_1
XFILLER_5_685 VGND VGND VPWR VPWR sky130_fd_sc_hd__decap_3
XFILLER_99_239 VGND VGND VPWR VPWR sky130_fd_sc_hd__decap_3
XFILLER_110_701 VGND VGND VPWR VPWR sky130_fd_sc_hd__decap_3
XFILLER_68_615 VGND VGND VPWR VPWR sky130_fd_sc_hd__decap_3
XFILLER_68_648 VGND VGND VPWR VPWR sky130_fd_sc_hd__decap_3
XFILLER_95_423 VGND VGND VPWR VPWR sky130_fd_sc_hd__decap_3
XFILLER_67_136 VGND VGND VPWR VPWR sky130_fd_sc_hd__decap_3
XFILLER_67_158 VGND VGND VPWR VPWR sky130_fd_sc_hd__decap_3
XFILLER_68_91 VGND VGND VPWR VPWR sky130_fd_sc_hd__fill_2
X_4090_ _7302_/Q _4979_/S _4088_/X _4089_/X VGND VGND VPWR VPWR _4090_/X sky130_fd_sc_hd__a211o_2
XFILLER_82_106 VGND VGND VPWR VPWR sky130_fd_sc_hd__decap_3
XFILLER_83_629 VGND VGND VPWR VPWR sky130_fd_sc_hd__decap_3
XFILLER_63_331 VGND VGND VPWR VPWR sky130_fd_sc_hd__decap_3
XFILLER_76_681 VGND VGND VPWR VPWR sky130_fd_sc_hd__decap_3
XFILLER_82_139 VGND VGND VPWR VPWR sky130_fd_sc_hd__fill_1
XFILLER_24_707 VGND VGND VPWR VPWR sky130_fd_sc_hd__decap_3
XFILLER_90_150 VGND VGND VPWR VPWR sky130_fd_sc_hd__decap_3
XFILLER_91_662 VGND VGND VPWR VPWR sky130_fd_sc_hd__decap_3
XFILLER_91_673 VGND VGND VPWR VPWR sky130_fd_sc_hd__decap_3
Xplace331 _3661_/X VGND VGND VPWR VPWR _3892_/A2 sky130_fd_sc_hd__buf_2
Xplace320 _3629_/A VGND VGND VPWR VPWR _3682_/A sky130_fd_sc_hd__buf_2
X_6800_ clkload9/A _6800_/D VGND VGND VPWR VPWR _6800_/Q sky130_fd_sc_hd__dfxtp_2
XFILLER_36_589 VGND VGND VPWR VPWR sky130_fd_sc_hd__decap_3
XFILLER_51_526 VGND VGND VPWR VPWR sky130_fd_sc_hd__decap_3
Xplace364 _3548_/X VGND VGND VPWR VPWR _4948_/A sky130_fd_sc_hd__buf_2
Xplace353 _3879_/B1 VGND VGND VPWR VPWR _3910_/B1 sky130_fd_sc_hd__buf_2
Xplace342 _5660_/B VGND VGND VPWR VPWR _3925_/A2 sky130_fd_sc_hd__buf_2
X_4992_ _4987_/A _4991_/Y _4814_/A VGND VGND VPWR VPWR _4992_/Y sky130_fd_sc_hd__a21oi_2
XFILLER_16_280 VGND VGND VPWR VPWR sky130_fd_sc_hd__decap_3
XFILLER_51_559 VGND VGND VPWR VPWR sky130_fd_sc_hd__fill_1
Xplace397 _5092_/C VGND VGND VPWR VPWR _4910_/A sky130_fd_sc_hd__buf_2
Xplace386 _4351_/B1 VGND VGND VPWR VPWR _4434_/B1 sky130_fd_sc_hd__buf_2
Xplace375 _4422_/A2 VGND VGND VPWR VPWR _4131_/A2 sky130_fd_sc_hd__buf_2
X_6731_ _6923_/CLK _6731_/D VGND VGND VPWR VPWR _6731_/Q sky130_fd_sc_hd__dfxtp_2
X_3943_ _7368_/Q _4486_/A0 _3952_/S VGND VGND VPWR VPWR _7368_/D sky130_fd_sc_hd__mux2_2
XTAP_TAPCELL_ROW_102_1535 VGND VPWR sky130_fd_sc_hd__tapvpwrvgnd_1
X_6662_ _6662_/A VGND VGND VPWR VPWR _6662_/Y sky130_fd_sc_hd__inv_2
X_3874_ _5104_/A _3874_/B VGND VGND VPWR VPWR _3874_/X sky130_fd_sc_hd__or2_2
Xclkbuf_3_2__f_clk clkbuf_0_clk/X VGND VGND VPWR VPWR clkbuf_3_2__f_clk/X sky130_fd_sc_hd__clkbuf_16
X_5613_ _5613_/A _5633_/B VGND VGND VPWR VPWR _7021_/D sky130_fd_sc_hd__or2_2
X_6593_ _6593_/A VGND VGND VPWR VPWR _6593_/Y sky130_fd_sc_hd__inv_2
XFILLER_117_366 VGND VGND VPWR VPWR sky130_fd_sc_hd__decap_3
X_7214_ _7374_/CLK _7214_/D _6494_/Y VGND VGND VPWR VPWR _7214_/Q sky130_fd_sc_hd__dfrtp_2
X_4426_ _4446_/A _4426_/B VGND VGND VPWR VPWR _4813_/A sky130_fd_sc_hd__or2_2
X_7145_ _7402_/CLK _7145_/D _6425_/Y VGND VGND VPWR VPWR _7145_/Q sky130_fd_sc_hd__dfrtp_2
XTAP_TAPCELL_ROW_113_1675 VGND VPWR sky130_fd_sc_hd__tapvpwrvgnd_1
XFILLER_100_200 VGND VGND VPWR VPWR sky130_fd_sc_hd__decap_3
XFILLER_101_712 VGND VGND VPWR VPWR sky130_fd_sc_hd__fill_2
XFILLER_113_561 VGND VGND VPWR VPWR sky130_fd_sc_hd__fill_2
XFILLER_58_103 VGND VGND VPWR VPWR sky130_fd_sc_hd__decap_3
XFILLER_59_626 VGND VGND VPWR VPWR sky130_fd_sc_hd__decap_3
X_4357_ _4352_/X _4356_/X _4327_/A VGND VGND VPWR VPWR _4367_/C sky130_fd_sc_hd__o21ai_2
XFILLER_113_594 VGND VGND VPWR VPWR sky130_fd_sc_hd__decap_3
XFILLER_58_125 VGND VGND VPWR VPWR sky130_fd_sc_hd__decap_3
XFILLER_58_147 VGND VGND VPWR VPWR sky130_fd_sc_hd__decap_3
XFILLER_59_659 VGND VGND VPWR VPWR sky130_fd_sc_hd__decap_3
XFILLER_86_445 VGND VGND VPWR VPWR sky130_fd_sc_hd__decap_3
X_7076_ _7403_/CLK _7076_/D _6356_/Y VGND VGND VPWR VPWR _7076_/Q sky130_fd_sc_hd__dfrtp_2
X_4288_ _4394_/A _4337_/B _4288_/C _4288_/D VGND VGND VPWR VPWR _4288_/X sky130_fd_sc_hd__or4_4
X_3308_ _3324_/A _6979_/Q VGND VGND VPWR VPWR _5118_/C sky130_fd_sc_hd__nand2_2
XFILLER_46_309 VGND VGND VPWR VPWR sky130_fd_sc_hd__decap_3
XFILLER_74_618 VGND VGND VPWR VPWR sky130_fd_sc_hd__decap_3
XFILLER_100_299 VGND VGND VPWR VPWR sky130_fd_sc_hd__decap_3
XTAP_TAPCELL_ROW_68_1110 VGND VPWR sky130_fd_sc_hd__tapvpwrvgnd_1
XFILLER_27_567 VGND VGND VPWR VPWR sky130_fd_sc_hd__decap_3
XFILLER_66_191 VGND VGND VPWR VPWR sky130_fd_sc_hd__decap_3
XFILLER_82_640 VGND VGND VPWR VPWR sky130_fd_sc_hd__decap_3
XFILLER_82_651 VGND VGND VPWR VPWR sky130_fd_sc_hd__decap_3
XFILLER_81_161 VGND VGND VPWR VPWR sky130_fd_sc_hd__decap_3
XFILLER_82_684 VGND VGND VPWR VPWR sky130_fd_sc_hd__decap_3
XFILLER_14_239 VGND VGND VPWR VPWR sky130_fd_sc_hd__decap_3
XFILLER_81_194 VGND VGND VPWR VPWR sky130_fd_sc_hd__decap_3
X_6929_ clkload4/A _6929_/D VGND VGND VPWR VPWR _6929_/Q sky130_fd_sc_hd__dfxtp_2
XFILLER_80_15 VGND VGND VPWR VPWR sky130_fd_sc_hd__decap_3
XTAP_TAPCELL_ROW_12_407 VGND VPWR sky130_fd_sc_hd__tapvpwrvgnd_1
XFILLER_6_416 VGND VGND VPWR VPWR sky130_fd_sc_hd__decap_3
XFILLER_108_322 VGND VGND VPWR VPWR sky130_fd_sc_hd__decap_3
XFILLER_13_97 VGND VGND VPWR VPWR sky130_fd_sc_hd__decap_3
XFILLER_6_438 VGND VGND VPWR VPWR sky130_fd_sc_hd__decap_3
XTAP_TAPCELL_ROW_79_1250 VGND VPWR sky130_fd_sc_hd__tapvpwrvgnd_1
XFILLER_89_57 VGND VGND VPWR VPWR sky130_fd_sc_hd__decap_3
XFILLER_2_622 VGND VGND VPWR VPWR sky130_fd_sc_hd__decap_3
XFILLER_89_79 VGND VGND VPWR VPWR sky130_fd_sc_hd__decap_3
XFILLER_104_550 VGND VGND VPWR VPWR sky130_fd_sc_hd__decap_3
XFILLER_2_666 VGND VGND VPWR VPWR sky130_fd_sc_hd__decap_3
XFILLER_2_699 VGND VGND VPWR VPWR sky130_fd_sc_hd__fill_1
XFILLER_77_423 VGND VGND VPWR VPWR sky130_fd_sc_hd__decap_3
XFILLER_49_125 VGND VGND VPWR VPWR sky130_fd_sc_hd__decap_3
XFILLER_49_169 VGND VGND VPWR VPWR sky130_fd_sc_hd__fill_1
XFILLER_65_629 VGND VGND VPWR VPWR sky130_fd_sc_hd__decap_3
XFILLER_77_467 VGND VGND VPWR VPWR sky130_fd_sc_hd__decap_3
XFILLER_92_415 VGND VGND VPWR VPWR sky130_fd_sc_hd__decap_3
XFILLER_58_681 VGND VGND VPWR VPWR sky130_fd_sc_hd__decap_3
XFILLER_45_331 VGND VGND VPWR VPWR sky130_fd_sc_hd__decap_3
XFILLER_57_191 VGND VGND VPWR VPWR sky130_fd_sc_hd__decap_3
XFILLER_73_662 VGND VGND VPWR VPWR sky130_fd_sc_hd__decap_3
Xhold1190 _7287_/Q VGND VGND VPWR VPWR _4587_/A sky130_fd_sc_hd__dlygate4sd3_1
XFILLER_18_589 VGND VGND VPWR VPWR sky130_fd_sc_hd__decap_3
XFILLER_33_515 VGND VGND VPWR VPWR sky130_fd_sc_hd__decap_3
XFILLER_60_312 VGND VGND VPWR VPWR sky130_fd_sc_hd__decap_3
XFILLER_72_150 VGND VGND VPWR VPWR sky130_fd_sc_hd__decap_3
XFILLER_73_673 VGND VGND VPWR VPWR sky130_fd_sc_hd__decap_3
XFILLER_72_183 VGND VGND VPWR VPWR sky130_fd_sc_hd__decap_3
XFILLER_13_261 VGND VGND VPWR VPWR sky130_fd_sc_hd__decap_3
XFILLER_9_276 VGND VGND VPWR VPWR sky130_fd_sc_hd__decap_3
Xclkload13 _7350_/CLK VGND VGND VPWR VPWR clkload13/X sky130_fd_sc_hd__clkbuf_1
Xclkload24 _7403_/CLK VGND VGND VPWR VPWR clkload24/X sky130_fd_sc_hd__clkbuf_1
Xclkload35 _7372_/CLK VGND VGND VPWR VPWR clkload35/Y sky130_fd_sc_hd__bufinv_16
X_3590_ _3590_/A _3590_/B _3590_/C VGND VGND VPWR VPWR _3620_/C sky130_fd_sc_hd__and3_2
XFILLER_9_287 VGND VGND VPWR VPWR sky130_fd_sc_hd__decap_3
XFILLER_5_482 VGND VGND VPWR VPWR sky130_fd_sc_hd__decap_3
X_5260_ _5260_/A0 _4964_/X _5274_/S VGND VGND VPWR VPWR _7200_/D sky130_fd_sc_hd__mux2_2
XFILLER_79_90 VGND VGND VPWR VPWR sky130_fd_sc_hd__decap_3
X_4211_ _4633_/A _4143_/X _4206_/X _4384_/A _4210_/X VGND VGND VPWR VPWR _4778_/A
+ sky130_fd_sc_hd__a221oi_2
XFILLER_68_401 VGND VGND VPWR VPWR sky130_fd_sc_hd__decap_3
XFILLER_96_710 VGND VGND VPWR VPWR sky130_fd_sc_hd__decap_3
XFILLER_110_542 VGND VGND VPWR VPWR sky130_fd_sc_hd__decap_3
XFILLER_68_445 VGND VGND VPWR VPWR sky130_fd_sc_hd__decap_3
X_4142_ _4205_/A _4142_/B _4142_/C VGND VGND VPWR VPWR _4142_/X sky130_fd_sc_hd__and3_2
XFILLER_28_309 VGND VGND VPWR VPWR sky130_fd_sc_hd__fill_2
X_4073_ _7275_/Q _4437_/A2 _4070_/X _4072_/X VGND VGND VPWR VPWR _4073_/X sky130_fd_sc_hd__a211o_2
XFILLER_55_139 VGND VGND VPWR VPWR sky130_fd_sc_hd__decap_3
XFILLER_64_640 VGND VGND VPWR VPWR sky130_fd_sc_hd__decap_3
XFILLER_64_651 VGND VGND VPWR VPWR sky130_fd_sc_hd__decap_3
XFILLER_24_504 VGND VGND VPWR VPWR sky130_fd_sc_hd__decap_3
XFILLER_63_172 VGND VGND VPWR VPWR sky130_fd_sc_hd__decap_3
XFILLER_64_684 VGND VGND VPWR VPWR sky130_fd_sc_hd__decap_3
XFILLER_70_109 VGND VGND VPWR VPWR sky130_fd_sc_hd__decap_3
XFILLER_51_334 VGND VGND VPWR VPWR sky130_fd_sc_hd__fill_2
XFILLER_51_345 VGND VGND VPWR VPWR sky130_fd_sc_hd__decap_3
XFILLER_63_183 VGND VGND VPWR VPWR sky130_fd_sc_hd__decap_3
XFILLER_91_492 VGND VGND VPWR VPWR sky130_fd_sc_hd__decap_3
X_4975_ _5579_/S _4975_/B VGND VGND VPWR VPWR _4975_/Y sky130_fd_sc_hd__nand2_2
XFILLER_20_710 VGND VGND VPWR VPWR sky130_fd_sc_hd__decap_3
X_6714_ _6941_/CLK _6714_/D VGND VGND VPWR VPWR _6714_/Q sky130_fd_sc_hd__dfxtp_2
X_3926_ _6913_/Q _3926_/A2 _3926_/B1 _6777_/Q _3925_/X VGND VGND VPWR VPWR _3926_/X
+ sky130_fd_sc_hd__a221o_2
XTAP_TAPCELL_ROW_63_1051 VGND VPWR sky130_fd_sc_hd__tapvpwrvgnd_1
XTAP_TAPCELL_ROW_63_1040 VGND VPWR sky130_fd_sc_hd__tapvpwrvgnd_1
XFILLER_32_592 VGND VGND VPWR VPWR sky130_fd_sc_hd__decap_3
XFILLER_109_119 VGND VGND VPWR VPWR sky130_fd_sc_hd__decap_3
Xclkload7 clkload7/A VGND VGND VPWR VPWR clkload7/Y sky130_fd_sc_hd__clkinv_8
X_6645_ _6645_/A VGND VGND VPWR VPWR _6645_/Y sky130_fd_sc_hd__inv_2
X_3857_ _3857_/A1 _3857_/A2 _3856_/X VGND VGND VPWR VPWR _7387_/D sky130_fd_sc_hd__a21o_2
XFILLER_118_631 VGND VGND VPWR VPWR sky130_fd_sc_hd__decap_3
X_6576_ _6608_/A VGND VGND VPWR VPWR _6576_/Y sky130_fd_sc_hd__inv_2
X_3788_ _3741_/X _3785_/X _3787_/X _3735_/X VGND VGND VPWR VPWR _3788_/X sky130_fd_sc_hd__a22o_2
XFILLER_117_152 VGND VGND VPWR VPWR sky130_fd_sc_hd__decap_3
XFILLER_118_675 VGND VGND VPWR VPWR sky130_fd_sc_hd__decap_3
XFILLER_3_408 VGND VGND VPWR VPWR sky130_fd_sc_hd__decap_3
XFILLER_105_325 VGND VGND VPWR VPWR sky130_fd_sc_hd__decap_3
XFILLER_105_358 VGND VGND VPWR VPWR sky130_fd_sc_hd__decap_3
Xoutput595 _5655_/A VGND VGND VPWR VPWR alu_result_out[30] sky130_fd_sc_hd__clkdlybuf4s25_1
Xoutput584 _5657_/B VGND VGND VPWR VPWR alu_result_out[20] sky130_fd_sc_hd__clkdlybuf4s25_1
Xoutput573 _5658_/A VGND VGND VPWR VPWR alu_result_out[10] sky130_fd_sc_hd__clkdlybuf4s25_1
X_4409_ _4425_/A _4409_/B VGND VGND VPWR VPWR _4411_/B sky130_fd_sc_hd__nand2_2
XTAP_TAPCELL_ROW_74_1180 VGND VPWR sky130_fd_sc_hd__tapvpwrvgnd_1
XFILLER_115_33 VGND VGND VPWR VPWR sky130_fd_sc_hd__decap_3
XFILLER_59_445 VGND VGND VPWR VPWR sky130_fd_sc_hd__decap_3
X_7128_ _7344_/CLK _7128_/D _6408_/Y VGND VGND VPWR VPWR _7128_/Q sky130_fd_sc_hd__dfrtp_2
XFILLER_115_66 VGND VGND VPWR VPWR sky130_fd_sc_hd__decap_3
XFILLER_47_607 VGND VGND VPWR VPWR sky130_fd_sc_hd__decap_3
XFILLER_47_629 VGND VGND VPWR VPWR sky130_fd_sc_hd__decap_3
XFILLER_86_242 VGND VGND VPWR VPWR sky130_fd_sc_hd__fill_2
XFILLER_86_253 VGND VGND VPWR VPWR sky130_fd_sc_hd__decap_3
X_7059_ _7349_/CLK _7059_/D _6339_/Y VGND VGND VPWR VPWR _7059_/Q sky130_fd_sc_hd__dfrtp_2
XFILLER_101_586 VGND VGND VPWR VPWR sky130_fd_sc_hd__decap_3
XFILLER_115_99 VGND VGND VPWR VPWR sky130_fd_sc_hd__decap_3
XFILLER_46_139 VGND VGND VPWR VPWR sky130_fd_sc_hd__fill_1
XFILLER_86_297 VGND VGND VPWR VPWR sky130_fd_sc_hd__decap_3
XFILLER_55_662 VGND VGND VPWR VPWR sky130_fd_sc_hd__decap_3
XTAP_TAPCELL_ROW_45_819 VGND VPWR sky130_fd_sc_hd__tapvpwrvgnd_1
XFILLER_42_312 VGND VGND VPWR VPWR sky130_fd_sc_hd__decap_3
XFILLER_54_150 VGND VGND VPWR VPWR sky130_fd_sc_hd__decap_3
XFILLER_55_673 VGND VGND VPWR VPWR sky130_fd_sc_hd__decap_3
XFILLER_70_610 VGND VGND VPWR VPWR sky130_fd_sc_hd__decap_3
XFILLER_54_183 VGND VGND VPWR VPWR sky130_fd_sc_hd__decap_3
XFILLER_70_643 VGND VGND VPWR VPWR sky130_fd_sc_hd__fill_1
XFILLER_70_654 VGND VGND VPWR VPWR sky130_fd_sc_hd__decap_3
XFILLER_70_687 VGND VGND VPWR VPWR sky130_fd_sc_hd__decap_3
XTAP_TAPCELL_ROW_25_576 VGND VPWR sky130_fd_sc_hd__tapvpwrvgnd_1
XTAP_TAPCELL_ROW_25_565 VGND VPWR sky130_fd_sc_hd__tapvpwrvgnd_1
XFILLER_10_242 VGND VGND VPWR VPWR sky130_fd_sc_hd__decap_3
XFILLER_10_253 VGND VGND VPWR VPWR sky130_fd_sc_hd__decap_3
XFILLER_7_703 VGND VGND VPWR VPWR sky130_fd_sc_hd__decap_3
XFILLER_109_620 VGND VGND VPWR VPWR sky130_fd_sc_hd__decap_3
Xwire667 _4619_/Y VGND VGND VPWR VPWR wire667/X sky130_fd_sc_hd__clkdlybuf4s25_1
XFILLER_108_141 VGND VGND VPWR VPWR sky130_fd_sc_hd__decap_3
XFILLER_109_653 VGND VGND VPWR VPWR sky130_fd_sc_hd__decap_3
XFILLER_109_697 VGND VGND VPWR VPWR sky130_fd_sc_hd__decap_3
XFILLER_6_279 VGND VGND VPWR VPWR sky130_fd_sc_hd__decap_3
XFILLER_111_317 VGND VGND VPWR VPWR sky130_fd_sc_hd__decap_3
XFILLER_78_710 VGND VGND VPWR VPWR sky130_fd_sc_hd__decap_3
XFILLER_104_380 VGND VGND VPWR VPWR sky130_fd_sc_hd__decap_3
XFILLER_49_60 VGND VGND VPWR VPWR sky130_fd_sc_hd__decap_3
XFILLER_38_607 VGND VGND VPWR VPWR sky130_fd_sc_hd__decap_3
XFILLER_18_342 VGND VGND VPWR VPWR sky130_fd_sc_hd__decap_3
XFILLER_46_640 VGND VGND VPWR VPWR sky130_fd_sc_hd__decap_3
XFILLER_46_651 VGND VGND VPWR VPWR sky130_fd_sc_hd__decap_3
XFILLER_92_256 VGND VGND VPWR VPWR sky130_fd_sc_hd__fill_1
XFILLER_46_684 VGND VGND VPWR VPWR sky130_fd_sc_hd__decap_3
XFILLER_33_323 VGND VGND VPWR VPWR sky130_fd_sc_hd__decap_3
XFILLER_33_345 VGND VGND VPWR VPWR sky130_fd_sc_hd__decap_3
XFILLER_45_183 VGND VGND VPWR VPWR sky130_fd_sc_hd__decap_3
XFILLER_60_131 VGND VGND VPWR VPWR sky130_fd_sc_hd__decap_3
XFILLER_61_632 VGND VGND VPWR VPWR sky130_fd_sc_hd__decap_3
XFILLER_60_153 VGND VGND VPWR VPWR sky130_fd_sc_hd__fill_1
XFILLER_60_164 VGND VGND VPWR VPWR sky130_fd_sc_hd__decap_3
XFILLER_61_665 VGND VGND VPWR VPWR sky130_fd_sc_hd__decap_3
XFILLER_61_676 VGND VGND VPWR VPWR sky130_fd_sc_hd__decap_3
XFILLER_14_570 VGND VGND VPWR VPWR sky130_fd_sc_hd__decap_3
XFILLER_14_592 VGND VGND VPWR VPWR sky130_fd_sc_hd__decap_3
XFILLER_60_186 VGND VGND VPWR VPWR sky130_fd_sc_hd__decap_3
XFILLER_60_197 VGND VGND VPWR VPWR sky130_fd_sc_hd__decap_3
X_4760_ _4777_/A _4760_/B VGND VGND VPWR VPWR _4760_/Y sky130_fd_sc_hd__nand2_2
XFILLER_119_417 VGND VGND VPWR VPWR sky130_fd_sc_hd__decap_3
X_4691_ _7004_/Q _4665_/X _4804_/A _4757_/A VGND VGND VPWR VPWR _4749_/B sky130_fd_sc_hd__a31o_2
X_3711_ _3746_/A VGND VGND VPWR VPWR _3735_/A sky130_fd_sc_hd__inv_2
XPHY_EDGE_ROW_112_Right_112 VGND VGND VPWR VPWR sky130_fd_sc_hd__decap_3
X_6430_ _6550_/A VGND VGND VPWR VPWR _6430_/Y sky130_fd_sc_hd__inv_2
X_3642_ _6718_/Q _6808_/Q _6896_/Q _6944_/Q _3991_/B _3661_/B VGND VGND VPWR VPWR
+ _3642_/X sky130_fd_sc_hd__mux4_2
X_6361_ _6649_/A VGND VGND VPWR VPWR _6361_/Y sky130_fd_sc_hd__inv_2
XFILLER_114_100 VGND VGND VPWR VPWR sky130_fd_sc_hd__fill_1
XFILLER_115_623 VGND VGND VPWR VPWR sky130_fd_sc_hd__decap_3
X_5312_ _7174_/Q _4864_/X _5323_/S VGND VGND VPWR VPWR _7174_/D sky130_fd_sc_hd__mux2_2
X_3573_ _7316_/Q _3987_/S _4528_/B _7284_/Q VGND VGND VPWR VPWR _3573_/X sky130_fd_sc_hd__a22o_2
XPHY_EDGE_ROW_49_Right_49 VGND VGND VPWR VPWR sky130_fd_sc_hd__decap_3
XFILLER_114_122 VGND VGND VPWR VPWR sky130_fd_sc_hd__decap_3
XFILLER_114_144 VGND VGND VPWR VPWR sky130_fd_sc_hd__decap_3
XFILLER_115_656 VGND VGND VPWR VPWR sky130_fd_sc_hd__decap_3
XFILLER_5_290 VGND VGND VPWR VPWR sky130_fd_sc_hd__decap_3
XFILLER_88_507 VGND VGND VPWR VPWR sky130_fd_sc_hd__decap_3
X_6292_ _6608_/A VGND VGND VPWR VPWR _6292_/Y sky130_fd_sc_hd__inv_2
XFILLER_88_518 VGND VGND VPWR VPWR sky130_fd_sc_hd__decap_3
X_5243_ _5243_/A0 _4822_/X _5272_/S VGND VGND VPWR VPWR _7208_/D sky130_fd_sc_hd__mux2_2
XTAP_TAPCELL_ROW_110_1634 VGND VPWR sky130_fd_sc_hd__tapvpwrvgnd_1
XFILLER_29_629 VGND VGND VPWR VPWR sky130_fd_sc_hd__decap_3
XFILLER_56_404 VGND VGND VPWR VPWR sky130_fd_sc_hd__decap_3
XFILLER_68_253 VGND VGND VPWR VPWR sky130_fd_sc_hd__decap_3
XFILLER_84_713 VGND VGND VPWR VPWR sky130_fd_sc_hd__fill_1
XFILLER_96_551 VGND VGND VPWR VPWR sky130_fd_sc_hd__decap_3
X_4125_ _4205_/A _4117_/B _4117_/C _4124_/B VGND VGND VPWR VPWR _4125_/X sky130_fd_sc_hd__a31o_2
XFILLER_110_383 VGND VGND VPWR VPWR sky130_fd_sc_hd__fill_1
XFILLER_28_128 VGND VGND VPWR VPWR sky130_fd_sc_hd__decap_3
XFILLER_68_297 VGND VGND VPWR VPWR sky130_fd_sc_hd__decap_3
XFILLER_83_223 VGND VGND VPWR VPWR sky130_fd_sc_hd__fill_1
XFILLER_83_234 VGND VGND VPWR VPWR sky130_fd_sc_hd__fill_1
X_4056_ _7340_/Q _3945_/S _4428_/B1 _7148_/Q VGND VGND VPWR VPWR _4056_/X sky130_fd_sc_hd__a22o_2
XPHY_EDGE_ROW_58_Right_58 VGND VGND VPWR VPWR sky130_fd_sc_hd__decap_3
XFILLER_36_150 VGND VGND VPWR VPWR sky130_fd_sc_hd__decap_3
XFILLER_36_161 VGND VGND VPWR VPWR sky130_fd_sc_hd__decap_3
XFILLER_37_662 VGND VGND VPWR VPWR sky130_fd_sc_hd__decap_3
XFILLER_37_673 VGND VGND VPWR VPWR sky130_fd_sc_hd__decap_3
XFILLER_52_643 VGND VGND VPWR VPWR sky130_fd_sc_hd__fill_1
XFILLER_52_654 VGND VGND VPWR VPWR sky130_fd_sc_hd__decap_3
XFILLER_64_492 VGND VGND VPWR VPWR sky130_fd_sc_hd__decap_3
XFILLER_51_131 VGND VGND VPWR VPWR sky130_fd_sc_hd__decap_3
XFILLER_51_164 VGND VGND VPWR VPWR sky130_fd_sc_hd__decap_3
XFILLER_52_687 VGND VGND VPWR VPWR sky130_fd_sc_hd__decap_3
XFILLER_101_68 VGND VGND VPWR VPWR sky130_fd_sc_hd__decap_3
XFILLER_24_389 VGND VGND VPWR VPWR sky130_fd_sc_hd__decap_3
XFILLER_51_175 VGND VGND VPWR VPWR sky130_fd_sc_hd__decap_3
X_4958_ _4983_/B VGND VGND VPWR VPWR _4958_/Y sky130_fd_sc_hd__inv_2
X_4889_ _4890_/B _4889_/B VGND VGND VPWR VPWR _4889_/Y sky130_fd_sc_hd__xnor2_2
X_3909_ _3909_/A1 _5104_/A _3908_/X VGND VGND VPWR VPWR _7379_/D sky130_fd_sc_hd__a21o_2
XTAP_TAPCELL_ROW_50_877 VGND VPWR sky130_fd_sc_hd__tapvpwrvgnd_1
XTAP_TAPCELL_ROW_22_535 VGND VPWR sky130_fd_sc_hd__tapvpwrvgnd_1
X_6628_ _6630_/A VGND VGND VPWR VPWR _6628_/Y sky130_fd_sc_hd__inv_2
XTAP_TAPCELL_ROW_50_888 VGND VPWR sky130_fd_sc_hd__tapvpwrvgnd_1
XFILLER_106_601 VGND VGND VPWR VPWR sky130_fd_sc_hd__decap_3
XFILLER_20_595 VGND VGND VPWR VPWR sky130_fd_sc_hd__decap_3
XPHY_EDGE_ROW_67_Right_67 VGND VGND VPWR VPWR sky130_fd_sc_hd__decap_3
XFILLER_106_634 VGND VGND VPWR VPWR sky130_fd_sc_hd__decap_3
XFILLER_118_461 VGND VGND VPWR VPWR sky130_fd_sc_hd__decap_3
X_6559_ _6625_/A VGND VGND VPWR VPWR _6559_/Y sky130_fd_sc_hd__inv_2
XFILLER_105_111 VGND VGND VPWR VPWR sky130_fd_sc_hd__fill_1
XFILLER_105_144 VGND VGND VPWR VPWR sky130_fd_sc_hd__decap_3
XFILLER_106_645 VGND VGND VPWR VPWR sky130_fd_sc_hd__decap_3
XFILLER_3_249 VGND VGND VPWR VPWR sky130_fd_sc_hd__decap_3
XPHY_EDGE_ROW_5_Left_125 VGND VGND VPWR VPWR sky130_fd_sc_hd__decap_3
XFILLER_106_678 VGND VGND VPWR VPWR sky130_fd_sc_hd__decap_3
XFILLER_86_58 VGND VGND VPWR VPWR sky130_fd_sc_hd__decap_3
XFILLER_101_361 VGND VGND VPWR VPWR sky130_fd_sc_hd__decap_3
XFILLER_59_275 VGND VGND VPWR VPWR sky130_fd_sc_hd__decap_3
XFILLER_74_212 VGND VGND VPWR VPWR sky130_fd_sc_hd__fill_2
XPHY_EDGE_ROW_76_Right_76 VGND VGND VPWR VPWR sky130_fd_sc_hd__decap_3
XFILLER_28_640 VGND VGND VPWR VPWR sky130_fd_sc_hd__decap_3
XFILLER_28_651 VGND VGND VPWR VPWR sky130_fd_sc_hd__decap_3
XFILLER_74_234 VGND VGND VPWR VPWR sky130_fd_sc_hd__decap_3
XFILLER_74_256 VGND VGND VPWR VPWR sky130_fd_sc_hd__fill_2
XTAP_TAPCELL_ROW_58_977 VGND VPWR sky130_fd_sc_hd__tapvpwrvgnd_1
XFILLER_28_684 VGND VGND VPWR VPWR sky130_fd_sc_hd__decap_3
XFILLER_62_407 VGND VGND VPWR VPWR sky130_fd_sc_hd__decap_3
XFILLER_62_418 VGND VGND VPWR VPWR sky130_fd_sc_hd__fill_2
XTAP_TAPCELL_ROW_58_988 VGND VPWR sky130_fd_sc_hd__tapvpwrvgnd_1
XTAP_TAPCELL_ROW_2_282 VGND VPWR sky130_fd_sc_hd__tapvpwrvgnd_1
XFILLER_27_172 VGND VGND VPWR VPWR sky130_fd_sc_hd__decap_3
XFILLER_43_632 VGND VGND VPWR VPWR sky130_fd_sc_hd__decap_3
XFILLER_55_481 VGND VGND VPWR VPWR sky130_fd_sc_hd__decap_3
XFILLER_30_304 VGND VGND VPWR VPWR sky130_fd_sc_hd__decap_3
XFILLER_42_131 VGND VGND VPWR VPWR sky130_fd_sc_hd__decap_3
XFILLER_43_665 VGND VGND VPWR VPWR sky130_fd_sc_hd__decap_3
XFILLER_43_676 VGND VGND VPWR VPWR sky130_fd_sc_hd__decap_3
XFILLER_42_164 VGND VGND VPWR VPWR sky130_fd_sc_hd__decap_3
XFILLER_42_175 VGND VGND VPWR VPWR sky130_fd_sc_hd__decap_3
XFILLER_42_197 VGND VGND VPWR VPWR sky130_fd_sc_hd__decap_3
XFILLER_30_348 VGND VGND VPWR VPWR sky130_fd_sc_hd__decap_3
XFILLER_11_573 VGND VGND VPWR VPWR sky130_fd_sc_hd__decap_3
XFILLER_7_511 VGND VGND VPWR VPWR sky130_fd_sc_hd__decap_3
XPHY_EDGE_ROW_85_Right_85 VGND VGND VPWR VPWR sky130_fd_sc_hd__decap_3
XFILLER_116_409 VGND VGND VPWR VPWR sky130_fd_sc_hd__decap_3
XFILLER_109_461 VGND VGND VPWR VPWR sky130_fd_sc_hd__decap_3
XFILLER_7_588 VGND VGND VPWR VPWR sky130_fd_sc_hd__decap_3
XFILLER_112_604 VGND VGND VPWR VPWR sky130_fd_sc_hd__decap_3
XFILLER_112_637 VGND VGND VPWR VPWR sky130_fd_sc_hd__decap_3
XFILLER_112_648 VGND VGND VPWR VPWR sky130_fd_sc_hd__decap_3
XFILLER_2_282 VGND VGND VPWR VPWR sky130_fd_sc_hd__decap_3
XFILLER_97_326 VGND VGND VPWR VPWR sky130_fd_sc_hd__decap_3
XFILLER_97_337 VGND VGND VPWR VPWR sky130_fd_sc_hd__decap_3
XFILLER_97_348 VGND VGND VPWR VPWR sky130_fd_sc_hd__decap_3
XFILLER_111_169 VGND VGND VPWR VPWR sky130_fd_sc_hd__fill_2
XFILLER_66_713 VGND VGND VPWR VPWR sky130_fd_sc_hd__fill_1
XFILLER_78_551 VGND VGND VPWR VPWR sky130_fd_sc_hd__fill_2
XFILLER_78_562 VGND VGND VPWR VPWR sky130_fd_sc_hd__decap_3
XPHY_EDGE_ROW_94_Right_94 VGND VGND VPWR VPWR sky130_fd_sc_hd__decap_3
XFILLER_65_212 VGND VGND VPWR VPWR sky130_fd_sc_hd__decap_3
XFILLER_65_223 VGND VGND VPWR VPWR sky130_fd_sc_hd__fill_1
XFILLER_76_91 VGND VGND VPWR VPWR sky130_fd_sc_hd__decap_3
XFILLER_19_662 VGND VGND VPWR VPWR sky130_fd_sc_hd__decap_3
XFILLER_19_673 VGND VGND VPWR VPWR sky130_fd_sc_hd__decap_3
XFILLER_34_610 VGND VGND VPWR VPWR sky130_fd_sc_hd__decap_3
XFILLER_65_278 VGND VGND VPWR VPWR sky130_fd_sc_hd__fill_2
XPHY_EDGE_ROW_69_Left_189 VGND VGND VPWR VPWR sky130_fd_sc_hd__decap_3
XFILLER_34_643 VGND VGND VPWR VPWR sky130_fd_sc_hd__fill_1
XFILLER_46_492 VGND VGND VPWR VPWR sky130_fd_sc_hd__decap_3
XFILLER_80_237 VGND VGND VPWR VPWR sky130_fd_sc_hd__decap_3
XFILLER_34_654 VGND VGND VPWR VPWR sky130_fd_sc_hd__decap_3
XFILLER_34_687 VGND VGND VPWR VPWR sky130_fd_sc_hd__decap_3
XFILLER_21_326 VGND VGND VPWR VPWR sky130_fd_sc_hd__fill_2
XFILLER_21_337 VGND VGND VPWR VPWR sky130_fd_sc_hd__decap_3
XFILLER_33_175 VGND VGND VPWR VPWR sky130_fd_sc_hd__decap_3
X_4812_ _4827_/A _4827_/B VGND VGND VPWR VPWR _4812_/Y sky130_fd_sc_hd__nor2_2
XTAP_TAPCELL_ROW_60_1010 VGND VPWR sky130_fd_sc_hd__tapvpwrvgnd_1
X_4743_ _4745_/A _4081_/X _4741_/X _4742_/Y VGND VGND VPWR VPWR _4743_/X sky130_fd_sc_hd__a31o_2
XFILLER_119_225 VGND VGND VPWR VPWR sky130_fd_sc_hd__fill_1
X_6413_ _6638_/A VGND VGND VPWR VPWR _6413_/Y sky130_fd_sc_hd__inv_2
X_4674_ _6989_/Q _4677_/B VGND VGND VPWR VPWR _4674_/X sky130_fd_sc_hd__or2_2
XPHY_EDGE_ROW_78_Left_198 VGND VGND VPWR VPWR sky130_fd_sc_hd__decap_3
X_7393_ _7403_/CLK _7393_/D _6673_/Y VGND VGND VPWR VPWR _7393_/Q sky130_fd_sc_hd__dfrtp_2
X_3625_ _3618_/X _3619_/Y _3620_/X _3624_/X VGND VGND VPWR VPWR _3625_/X sky130_fd_sc_hd__a31o_2
XFILLER_1_709 VGND VGND VPWR VPWR sky130_fd_sc_hd__fill_2
X_6344_ _6664_/A VGND VGND VPWR VPWR _6344_/Y sky130_fd_sc_hd__inv_2
X_3556_ _3556_/A _3556_/B _3556_/C VGND VGND VPWR VPWR _3556_/X sky130_fd_sc_hd__or3_2
XFILLER_0_219 VGND VGND VPWR VPWR sky130_fd_sc_hd__decap_3
XFILLER_103_615 VGND VGND VPWR VPWR sky130_fd_sc_hd__fill_1
XFILLER_103_626 VGND VGND VPWR VPWR sky130_fd_sc_hd__decap_3
XFILLER_88_304 VGND VGND VPWR VPWR sky130_fd_sc_hd__decap_3
XFILLER_88_315 VGND VGND VPWR VPWR sky130_fd_sc_hd__fill_2
X_6275_ _6678_/A VGND VGND VPWR VPWR _6275_/Y sky130_fd_sc_hd__inv_2
XFILLER_102_103 VGND VGND VPWR VPWR sky130_fd_sc_hd__decap_3
XFILLER_102_136 VGND VGND VPWR VPWR sky130_fd_sc_hd__decap_3
XFILLER_103_659 VGND VGND VPWR VPWR sky130_fd_sc_hd__decap_3
XFILLER_115_497 VGND VGND VPWR VPWR sky130_fd_sc_hd__decap_3
XFILLER_88_326 VGND VGND VPWR VPWR sky130_fd_sc_hd__decap_3
X_3487_ _3469_/A _3469_/B _3449_/A _7247_/Q _3365_/A VGND VGND VPWR VPWR _3487_/X
+ sky130_fd_sc_hd__o2111a_2
XTAP_TAPCELL_ROW_71_1150 VGND VPWR sky130_fd_sc_hd__tapvpwrvgnd_1
XFILLER_29_426 VGND VGND VPWR VPWR sky130_fd_sc_hd__decap_3
X_5157_ _5157_/A0 _5156_/X _5159_/S VGND VGND VPWR VPWR _7248_/D sky130_fd_sc_hd__mux2_2
XFILLER_56_234 VGND VGND VPWR VPWR sky130_fd_sc_hd__decap_3
XFILLER_96_392 VGND VGND VPWR VPWR sky130_fd_sc_hd__decap_3
X_5088_ _5086_/A _4365_/X _5086_/X _5087_/Y _5020_/A VGND VGND VPWR VPWR _5088_/X
+ sky130_fd_sc_hd__a2111o_2
X_4108_ _4394_/A _4394_/B _4107_/X VGND VGND VPWR VPWR _4142_/C sky130_fd_sc_hd__or3b_2
XFILLER_112_12 VGND VGND VPWR VPWR sky130_fd_sc_hd__decap_3
XFILLER_25_610 VGND VGND VPWR VPWR sky130_fd_sc_hd__decap_3
XFILLER_56_278 VGND VGND VPWR VPWR sky130_fd_sc_hd__decap_3
XFILLER_84_576 VGND VGND VPWR VPWR sky130_fd_sc_hd__decap_3
X_4039_ _4039_/A _4458_/A VGND VGND VPWR VPWR _4040_/B sky130_fd_sc_hd__and2_2
XFILLER_112_56 VGND VGND VPWR VPWR sky130_fd_sc_hd__decap_3
XFILLER_25_632 VGND VGND VPWR VPWR sky130_fd_sc_hd__decap_3
XFILLER_71_248 VGND VGND VPWR VPWR sky130_fd_sc_hd__decap_3
XTAP_TAPCELL_ROW_55_947 VGND VPWR sky130_fd_sc_hd__tapvpwrvgnd_1
XFILLER_24_153 VGND VGND VPWR VPWR sky130_fd_sc_hd__decap_3
XFILLER_25_665 VGND VGND VPWR VPWR sky130_fd_sc_hd__decap_3
XFILLER_25_676 VGND VGND VPWR VPWR sky130_fd_sc_hd__decap_3
XFILLER_24_186 VGND VGND VPWR VPWR sky130_fd_sc_hd__decap_3
XFILLER_40_613 VGND VGND VPWR VPWR sky130_fd_sc_hd__decap_3
XFILLER_52_495 VGND VGND VPWR VPWR sky130_fd_sc_hd__decap_3
XFILLER_12_348 VGND VGND VPWR VPWR sky130_fd_sc_hd__decap_3
XFILLER_24_197 VGND VGND VPWR VPWR sky130_fd_sc_hd__decap_3
XFILLER_40_657 VGND VGND VPWR VPWR sky130_fd_sc_hd__decap_3
XTAP_TAPCELL_ROW_35_693 VGND VPWR sky130_fd_sc_hd__tapvpwrvgnd_1
XFILLER_115_3 VGND VGND VPWR VPWR sky130_fd_sc_hd__decap_3
XFILLER_106_442 VGND VGND VPWR VPWR sky130_fd_sc_hd__decap_3
XFILLER_4_536 VGND VGND VPWR VPWR sky130_fd_sc_hd__decap_3
XFILLER_106_475 VGND VGND VPWR VPWR sky130_fd_sc_hd__fill_1
XFILLER_4_569 VGND VGND VPWR VPWR sky130_fd_sc_hd__decap_3
XFILLER_79_337 VGND VGND VPWR VPWR sky130_fd_sc_hd__decap_3
XFILLER_97_57 VGND VGND VPWR VPWR sky130_fd_sc_hd__decap_3
XTAP_TAPCELL_ROW_7_341 VGND VPWR sky130_fd_sc_hd__tapvpwrvgnd_1
XFILLER_102_681 VGND VGND VPWR VPWR sky130_fd_sc_hd__decap_3
XFILLER_48_713 VGND VGND VPWR VPWR sky130_fd_sc_hd__fill_1
XFILLER_87_370 VGND VGND VPWR VPWR sky130_fd_sc_hd__fill_1
XFILLER_47_223 VGND VGND VPWR VPWR sky130_fd_sc_hd__fill_1
XFILLER_47_234 VGND VGND VPWR VPWR sky130_fd_sc_hd__decap_3
XFILLER_75_598 VGND VGND VPWR VPWR sky130_fd_sc_hd__decap_3
XTAP_TAPCELL_ROW_85_1319 VGND VPWR sky130_fd_sc_hd__tapvpwrvgnd_1
XFILLER_16_610 VGND VGND VPWR VPWR sky130_fd_sc_hd__decap_3
XFILLER_16_643 VGND VGND VPWR VPWR sky130_fd_sc_hd__fill_1
XFILLER_28_492 VGND VGND VPWR VPWR sky130_fd_sc_hd__decap_3
XFILLER_62_237 VGND VGND VPWR VPWR sky130_fd_sc_hd__decap_3
XFILLER_16_654 VGND VGND VPWR VPWR sky130_fd_sc_hd__decap_3
XFILLER_16_687 VGND VGND VPWR VPWR sky130_fd_sc_hd__decap_3
XFILLER_31_613 VGND VGND VPWR VPWR sky130_fd_sc_hd__decap_3
XFILLER_31_635 VGND VGND VPWR VPWR sky130_fd_sc_hd__decap_3
XFILLER_43_473 VGND VGND VPWR VPWR sky130_fd_sc_hd__decap_3
XFILLER_43_495 VGND VGND VPWR VPWR sky130_fd_sc_hd__fill_1
XFILLER_70_270 VGND VGND VPWR VPWR sky130_fd_sc_hd__decap_3
XFILLER_31_668 VGND VGND VPWR VPWR sky130_fd_sc_hd__decap_3
XFILLER_31_679 VGND VGND VPWR VPWR sky130_fd_sc_hd__decap_3
XFILLER_7_11 VGND VGND VPWR VPWR sky130_fd_sc_hd__fill_1
XFILLER_7_363 VGND VGND VPWR VPWR sky130_fd_sc_hd__decap_3
XTAP_TAPCELL_ROW_96_1459 VGND VPWR sky130_fd_sc_hd__tapvpwrvgnd_1
XFILLER_7_396 VGND VGND VPWR VPWR sky130_fd_sc_hd__decap_3
X_4390_ _7241_/Q _4433_/B _3947_/S _7209_/Q VGND VGND VPWR VPWR _4390_/X sky130_fd_sc_hd__a22o_2
X_3410_ _7219_/Q _4307_/A2 _4528_/B _7032_/Q VGND VGND VPWR VPWR _3410_/X sky130_fd_sc_hd__a22o_2
XFILLER_98_624 VGND VGND VPWR VPWR sky130_fd_sc_hd__decap_3
X_3341_ _3341_/A VGND VGND VPWR VPWR _4606_/A sky130_fd_sc_hd__inv_2
XFILLER_3_591 VGND VGND VPWR VPWR sky130_fd_sc_hd__decap_3
XFILLER_97_123 VGND VGND VPWR VPWR sky130_fd_sc_hd__decap_3
XFILLER_98_657 VGND VGND VPWR VPWR sky130_fd_sc_hd__decap_3
XFILLER_30_3 VGND VGND VPWR VPWR sky130_fd_sc_hd__fill_2
XFILLER_97_156 VGND VGND VPWR VPWR sky130_fd_sc_hd__decap_3
XFILLER_100_629 VGND VGND VPWR VPWR sky130_fd_sc_hd__decap_3
XFILLER_78_381 VGND VGND VPWR VPWR sky130_fd_sc_hd__decap_3
XFILLER_97_189 VGND VGND VPWR VPWR sky130_fd_sc_hd__decap_3
Xhold1008 _6709_/Q VGND VGND VPWR VPWR _5719_/A1 sky130_fd_sc_hd__dlygate4sd3_1
Xhold1019 _6712_/Q VGND VGND VPWR VPWR _5725_/A1 sky130_fd_sc_hd__dlygate4sd3_1
X_5011_ _4836_/S _6991_/D _5010_/X VGND VGND VPWR VPWR _5011_/X sky130_fd_sc_hd__o21a_2
XFILLER_38_223 VGND VGND VPWR VPWR sky130_fd_sc_hd__fill_1
XFILLER_93_340 VGND VGND VPWR VPWR sky130_fd_sc_hd__decap_3
XFILLER_26_418 VGND VGND VPWR VPWR sky130_fd_sc_hd__fill_2
XFILLER_38_256 VGND VGND VPWR VPWR sky130_fd_sc_hd__decap_3
XFILLER_66_587 VGND VGND VPWR VPWR sky130_fd_sc_hd__fill_1
XFILLER_81_513 VGND VGND VPWR VPWR sky130_fd_sc_hd__decap_3
XFILLER_19_470 VGND VGND VPWR VPWR sky130_fd_sc_hd__decap_3
XFILLER_53_237 VGND VGND VPWR VPWR sky130_fd_sc_hd__fill_1
XFILLER_81_546 VGND VGND VPWR VPWR sky130_fd_sc_hd__decap_3
XFILLER_93_384 VGND VGND VPWR VPWR sky130_fd_sc_hd__fill_1
X_6962_ _6968_/CLK _6962_/D VGND VGND VPWR VPWR _6962_/Q sky130_fd_sc_hd__dfxtp_2
X_6893_ _6941_/CLK _6893_/D VGND VGND VPWR VPWR _6893_/Q sky130_fd_sc_hd__dfxtp_2
XTAP_TAPCELL_ROW_52_906 VGND VPWR sky130_fd_sc_hd__tapvpwrvgnd_1
XFILLER_22_613 VGND VGND VPWR VPWR sky130_fd_sc_hd__decap_3
XFILLER_61_270 VGND VGND VPWR VPWR sky130_fd_sc_hd__fill_1
XTAP_TAPCELL_ROW_105_1566 VGND VPWR sky130_fd_sc_hd__tapvpwrvgnd_1
XFILLER_22_657 VGND VGND VPWR VPWR sky130_fd_sc_hd__decap_3
XFILLER_61_281 VGND VGND VPWR VPWR sky130_fd_sc_hd__fill_2
XTAP_TAPCELL_ROW_32_663 VGND VPWR sky130_fd_sc_hd__tapvpwrvgnd_1
XTAP_TAPCELL_ROW_32_652 VGND VPWR sky130_fd_sc_hd__tapvpwrvgnd_1
XPHY_EDGE_ROW_86_Left_206 VGND VGND VPWR VPWR sky130_fd_sc_hd__decap_3
XFILLER_108_707 VGND VGND VPWR VPWR sky130_fd_sc_hd__decap_3
XFILLER_30_690 VGND VGND VPWR VPWR sky130_fd_sc_hd__decap_3
X_4726_ _4832_/A _5655_/A _3670_/X _4467_/B VGND VGND VPWR VPWR _4726_/X sky130_fd_sc_hd__o211a_2
X_4657_ _4720_/A _4655_/X _3548_/X VGND VGND VPWR VPWR _4658_/B sky130_fd_sc_hd__a21oi_2
X_7376_ _7388_/CLK _7376_/D _6656_/Y VGND VGND VPWR VPWR _7376_/Q sky130_fd_sc_hd__dfrtp_2
Xhold820 _6787_/Q VGND VGND VPWR VPWR _6787_/D sky130_fd_sc_hd__dlygate4sd3_1
XFILLER_107_12 VGND VGND VPWR VPWR sky130_fd_sc_hd__decap_3
XFILLER_1_517 VGND VGND VPWR VPWR sky130_fd_sc_hd__decap_3
Xhold831 _6906_/Q VGND VGND VPWR VPWR _6906_/D sky130_fd_sc_hd__dlygate4sd3_1
Xhold842 _6745_/Q VGND VGND VPWR VPWR _6745_/D sky130_fd_sc_hd__dlygate4sd3_1
Xhold853 _6809_/Q VGND VGND VPWR VPWR _6809_/D sky130_fd_sc_hd__dlygate4sd3_1
Xhold864 _6859_/Q VGND VGND VPWR VPWR _6859_/D sky130_fd_sc_hd__dlygate4sd3_1
X_6327_ _6550_/A VGND VGND VPWR VPWR _6327_/Y sky130_fd_sc_hd__inv_2
XFILLER_103_423 VGND VGND VPWR VPWR sky130_fd_sc_hd__decap_3
XFILLER_88_123 VGND VGND VPWR VPWR sky130_fd_sc_hd__decap_3
XFILLER_89_635 VGND VGND VPWR VPWR sky130_fd_sc_hd__decap_3
Xhold875 _6734_/Q VGND VGND VPWR VPWR _6734_/D sky130_fd_sc_hd__dlygate4sd3_1
Xhold886 _6758_/Q VGND VGND VPWR VPWR _6758_/D sky130_fd_sc_hd__dlygate4sd3_1
Xhold897 _6851_/Q VGND VGND VPWR VPWR _6851_/D sky130_fd_sc_hd__dlygate4sd3_1
X_3539_ _3544_/A _3544_/B VGND VGND VPWR VPWR _3547_/A sky130_fd_sc_hd__nand2_2
XFILLER_103_467 VGND VGND VPWR VPWR sky130_fd_sc_hd__decap_3
XFILLER_107_78 VGND VGND VPWR VPWR sky130_fd_sc_hd__decap_3
XFILLER_88_156 VGND VGND VPWR VPWR sky130_fd_sc_hd__decap_3
XFILLER_89_668 VGND VGND VPWR VPWR sky130_fd_sc_hd__decap_3
XFILLER_89_679 VGND VGND VPWR VPWR sky130_fd_sc_hd__decap_3
XFILLER_103_478 VGND VGND VPWR VPWR sky130_fd_sc_hd__decap_3
XFILLER_69_370 VGND VGND VPWR VPWR sky130_fd_sc_hd__decap_3
XFILLER_76_329 VGND VGND VPWR VPWR sky130_fd_sc_hd__decap_3
XFILLER_88_189 VGND VGND VPWR VPWR sky130_fd_sc_hd__decap_3
X_5209_ _5209_/A _5225_/B VGND VGND VPWR VPWR _7224_/D sky130_fd_sc_hd__and2_2
XTAP_TAPCELL_ROW_4_311 VGND VPWR sky130_fd_sc_hd__tapvpwrvgnd_1
XPHY_EDGE_ROW_95_Left_215 VGND VGND VPWR VPWR sky130_fd_sc_hd__decap_3
XFILLER_29_223 VGND VGND VPWR VPWR sky130_fd_sc_hd__fill_1
XFILLER_17_418 VGND VGND VPWR VPWR sky130_fd_sc_hd__decap_3
XFILLER_29_267 VGND VGND VPWR VPWR sky130_fd_sc_hd__decap_3
XFILLER_44_237 VGND VGND VPWR VPWR sky130_fd_sc_hd__decap_3
XFILLER_72_579 VGND VGND VPWR VPWR sky130_fd_sc_hd__fill_1
XFILLER_13_635 VGND VGND VPWR VPWR sky130_fd_sc_hd__decap_3
XFILLER_25_473 VGND VGND VPWR VPWR sky130_fd_sc_hd__fill_2
XFILLER_25_484 VGND VGND VPWR VPWR sky130_fd_sc_hd__decap_3
XFILLER_52_270 VGND VGND VPWR VPWR sky130_fd_sc_hd__decap_3
XFILLER_13_668 VGND VGND VPWR VPWR sky130_fd_sc_hd__decap_3
XFILLER_9_617 VGND VGND VPWR VPWR sky130_fd_sc_hd__decap_3
XFILLER_9_606 VGND VGND VPWR VPWR sky130_fd_sc_hd__decap_3
XFILLER_13_679 VGND VGND VPWR VPWR sky130_fd_sc_hd__decap_3
XFILLER_32_85 VGND VGND VPWR VPWR sky130_fd_sc_hd__fill_1
XFILLER_4_300 VGND VGND VPWR VPWR sky130_fd_sc_hd__decap_3
XTAP_TAPCELL_ROW_10_379 VGND VPWR sky130_fd_sc_hd__tapvpwrvgnd_1
XFILLER_106_250 VGND VGND VPWR VPWR sky130_fd_sc_hd__fill_2
XFILLER_79_134 VGND VGND VPWR VPWR sky130_fd_sc_hd__decap_3
XFILLER_0_561 VGND VGND VPWR VPWR sky130_fd_sc_hd__fill_1
XFILLER_67_318 VGND VGND VPWR VPWR sky130_fd_sc_hd__decap_3
XFILLER_67_329 VGND VGND VPWR VPWR sky130_fd_sc_hd__decap_3
XFILLER_79_178 VGND VGND VPWR VPWR sky130_fd_sc_hd__decap_3
XFILLER_94_115 VGND VGND VPWR VPWR sky130_fd_sc_hd__fill_2
XFILLER_95_638 VGND VGND VPWR VPWR sky130_fd_sc_hd__decap_3
XFILLER_57_60 VGND VGND VPWR VPWR sky130_fd_sc_hd__decap_3
XFILLER_88_690 VGND VGND VPWR VPWR sky130_fd_sc_hd__decap_3
XFILLER_75_340 VGND VGND VPWR VPWR sky130_fd_sc_hd__decap_3
XFILLER_35_237 VGND VGND VPWR VPWR sky130_fd_sc_hd__decap_3
XFILLER_48_598 VGND VGND VPWR VPWR sky130_fd_sc_hd__fill_1
XFILLER_63_535 VGND VGND VPWR VPWR sky130_fd_sc_hd__decap_3
XFILLER_75_384 VGND VGND VPWR VPWR sky130_fd_sc_hd__fill_1
Xplace502 _7010_/Q VGND VGND VPWR VPWR _7010_/D sky130_fd_sc_hd__buf_2
Xplace513 _6979_/Q VGND VGND VPWR VPWR _5129_/B sky130_fd_sc_hd__buf_2
XFILLER_16_451 VGND VGND VPWR VPWR sky130_fd_sc_hd__decap_3
XFILLER_35_259 VGND VGND VPWR VPWR sky130_fd_sc_hd__decap_3
XFILLER_90_354 VGND VGND VPWR VPWR sky130_fd_sc_hd__decap_3
XFILLER_90_365 VGND VGND VPWR VPWR sky130_fd_sc_hd__decap_3
Xplace524 _6686_/A VGND VGND VPWR VPWR _6683_/A sky130_fd_sc_hd__buf_2
Xplace535 _6613_/A VGND VGND VPWR VPWR _6645_/A sky130_fd_sc_hd__buf_2
Xplace546 _6613_/A VGND VGND VPWR VPWR _6642_/A sky130_fd_sc_hd__buf_2
XFILLER_50_218 VGND VGND VPWR VPWR sky130_fd_sc_hd__decap_3
Xplace557 _6612_/A VGND VGND VPWR VPWR _6640_/A sky130_fd_sc_hd__buf_2
Xplace568 _6563_/A VGND VGND VPWR VPWR _6627_/A sky130_fd_sc_hd__buf_2
XTAP_TAPCELL_ROW_18_479 VGND VPWR sky130_fd_sc_hd__tapvpwrvgnd_1
XFILLER_43_281 VGND VGND VPWR VPWR sky130_fd_sc_hd__decap_3
X_3890_ _6963_/Q _3661_/X _3890_/B1 _6945_/Q VGND VGND VPWR VPWR _3890_/X sky130_fd_sc_hd__a22o_2
XFILLER_12_690 VGND VGND VPWR VPWR sky130_fd_sc_hd__decap_3
XFILLER_8_672 VGND VGND VPWR VPWR sky130_fd_sc_hd__decap_3
XFILLER_117_559 VGND VGND VPWR VPWR sky130_fd_sc_hd__fill_1
X_7230_ _7360_/CLK _7230_/D _6510_/Y VGND VGND VPWR VPWR _7230_/Q sky130_fd_sc_hd__dfrtp_2
X_4442_ _4813_/A _4827_/A VGND VGND VPWR VPWR _4779_/A sky130_fd_sc_hd__or2_2
X_7161_ _7354_/CLK _7161_/D _6441_/Y VGND VGND VPWR VPWR _7161_/Q sky130_fd_sc_hd__dfrtp_2
X_4373_ _5018_/A _5018_/B VGND VGND VPWR VPWR _4373_/Y sky130_fd_sc_hd__nand2_2
XFILLER_112_242 VGND VGND VPWR VPWR sky130_fd_sc_hd__decap_3
X_7092_ _7350_/CLK _7092_/D _6372_/Y VGND VGND VPWR VPWR _7092_/Q sky130_fd_sc_hd__dfrtp_2
X_3324_ _3324_/A _4467_/A _4696_/B VGND VGND VPWR VPWR _3324_/X sky130_fd_sc_hd__or3_2
XFILLER_112_253 VGND VGND VPWR VPWR sky130_fd_sc_hd__decap_3
XFILLER_86_638 VGND VGND VPWR VPWR sky130_fd_sc_hd__decap_3
XFILLER_100_437 VGND VGND VPWR VPWR sky130_fd_sc_hd__decap_3
XFILLER_39_532 VGND VGND VPWR VPWR sky130_fd_sc_hd__fill_1
XFILLER_85_137 VGND VGND VPWR VPWR sky130_fd_sc_hd__decap_3
XFILLER_54_513 VGND VGND VPWR VPWR sky130_fd_sc_hd__decap_3
XFILLER_66_362 VGND VGND VPWR VPWR sky130_fd_sc_hd__fill_2
XFILLER_94_660 VGND VGND VPWR VPWR sky130_fd_sc_hd__decap_3
XFILLER_26_215 VGND VGND VPWR VPWR sky130_fd_sc_hd__decap_3
XFILLER_39_598 VGND VGND VPWR VPWR sky130_fd_sc_hd__decap_3
XFILLER_81_310 VGND VGND VPWR VPWR sky130_fd_sc_hd__decap_3
XFILLER_93_181 VGND VGND VPWR VPWR sky130_fd_sc_hd__decap_3
XFILLER_94_693 VGND VGND VPWR VPWR sky130_fd_sc_hd__decap_3
XTAP_TAPCELL_ROW_37_722 VGND VPWR sky130_fd_sc_hd__tapvpwrvgnd_1
XFILLER_54_557 VGND VGND VPWR VPWR sky130_fd_sc_hd__decap_3
XFILLER_54_568 VGND VGND VPWR VPWR sky130_fd_sc_hd__fill_2
XFILLER_81_365 VGND VGND VPWR VPWR sky130_fd_sc_hd__decap_3
X_6945_ clkload6/A _6945_/D VGND VGND VPWR VPWR _6945_/Q sky130_fd_sc_hd__dfxtp_2
XFILLER_22_421 VGND VGND VPWR VPWR sky130_fd_sc_hd__decap_3
X_6876_ _6923_/CLK _6876_/D VGND VGND VPWR VPWR _6876_/Q sky130_fd_sc_hd__dfxtp_2
XTAP_TAPCELL_ROW_66_1082 VGND VPWR sky130_fd_sc_hd__tapvpwrvgnd_1
XFILLER_10_616 VGND VGND VPWR VPWR sky130_fd_sc_hd__decap_3
XFILLER_108_526 VGND VGND VPWR VPWR sky130_fd_sc_hd__decap_3
X_4709_ _7002_/Q _7003_/Q _4826_/A VGND VGND VPWR VPWR _4801_/A sky130_fd_sc_hd__and3_2
XTAP_TAPCELL_ROW_118_1735 VGND VPWR sky130_fd_sc_hd__tapvpwrvgnd_1
XFILLER_118_22 VGND VGND VPWR VPWR sky130_fd_sc_hd__decap_3
XFILLER_118_44 VGND VGND VPWR VPWR sky130_fd_sc_hd__decap_3
XFILLER_104_710 VGND VGND VPWR VPWR sky130_fd_sc_hd__decap_3
XFILLER_116_570 VGND VGND VPWR VPWR sky130_fd_sc_hd__decap_3
XFILLER_116_592 VGND VGND VPWR VPWR sky130_fd_sc_hd__decap_3
XFILLER_118_77 VGND VGND VPWR VPWR sky130_fd_sc_hd__decap_3
XFILLER_118_88 VGND VGND VPWR VPWR sky130_fd_sc_hd__decap_3
XFILLER_89_421 VGND VGND VPWR VPWR sky130_fd_sc_hd__decap_3
X_7359_ _7360_/CLK _7359_/D _6639_/Y VGND VGND VPWR VPWR _7359_/Q sky130_fd_sc_hd__dfrtp_2
XFILLER_103_220 VGND VGND VPWR VPWR sky130_fd_sc_hd__decap_3
XFILLER_78_59 VGND VGND VPWR VPWR sky130_fd_sc_hd__decap_3
Xhold683 _6944_/Q VGND VGND VPWR VPWR _6944_/D sky130_fd_sc_hd__dlygate4sd3_1
Xhold694 _6783_/Q VGND VGND VPWR VPWR _6783_/D sky130_fd_sc_hd__dlygate4sd3_1
XFILLER_103_264 VGND VGND VPWR VPWR sky130_fd_sc_hd__decap_3
XFILLER_1_369 VGND VGND VPWR VPWR sky130_fd_sc_hd__fill_1
XFILLER_77_638 VGND VGND VPWR VPWR sky130_fd_sc_hd__decap_3
XFILLER_57_340 VGND VGND VPWR VPWR sky130_fd_sc_hd__fill_1
XFILLER_85_671 VGND VGND VPWR VPWR sky130_fd_sc_hd__fill_1
XFILLER_92_619 VGND VGND VPWR VPWR sky130_fd_sc_hd__decap_3
XFILLER_45_524 VGND VGND VPWR VPWR sky130_fd_sc_hd__decap_3
XFILLER_85_682 VGND VGND VPWR VPWR sky130_fd_sc_hd__decap_3
XFILLER_72_365 VGND VGND VPWR VPWR sky130_fd_sc_hd__decap_3
XFILLER_32_218 VGND VGND VPWR VPWR sky130_fd_sc_hd__fill_1
XFILLER_60_527 VGND VGND VPWR VPWR sky130_fd_sc_hd__decap_3
XFILLER_25_281 VGND VGND VPWR VPWR sky130_fd_sc_hd__decap_3
XTAP_TAPCELL_ROW_15_449 VGND VPWR sky130_fd_sc_hd__tapvpwrvgnd_1
XFILLER_40_295 VGND VGND VPWR VPWR sky130_fd_sc_hd__decap_3
XFILLER_9_458 VGND VGND VPWR VPWR sky130_fd_sc_hd__decap_3
XFILLER_5_620 VGND VGND VPWR VPWR sky130_fd_sc_hd__decap_3
XFILLER_114_518 VGND VGND VPWR VPWR sky130_fd_sc_hd__decap_3
XFILLER_5_653 VGND VGND VPWR VPWR sky130_fd_sc_hd__decap_3
XTAP_TAPCELL_ROW_93_1418 VGND VPWR sky130_fd_sc_hd__tapvpwrvgnd_1
XFILLER_99_207 VGND VGND VPWR VPWR sky130_fd_sc_hd__decap_3
XFILLER_107_592 VGND VGND VPWR VPWR sky130_fd_sc_hd__decap_3
XFILLER_5_697 VGND VGND VPWR VPWR sky130_fd_sc_hd__decap_3
XFILLER_110_713 VGND VGND VPWR VPWR sky130_fd_sc_hd__fill_1
XFILLER_68_627 VGND VGND VPWR VPWR sky130_fd_sc_hd__decap_3
XFILLER_67_148 VGND VGND VPWR VPWR sky130_fd_sc_hd__decap_3
XFILLER_36_502 VGND VGND VPWR VPWR sky130_fd_sc_hd__decap_3
XFILLER_48_362 VGND VGND VPWR VPWR sky130_fd_sc_hd__fill_2
XFILLER_76_660 VGND VGND VPWR VPWR sky130_fd_sc_hd__decap_3
XFILLER_83_608 VGND VGND VPWR VPWR sky130_fd_sc_hd__decap_3
XFILLER_48_395 VGND VGND VPWR VPWR sky130_fd_sc_hd__fill_2
XFILLER_63_310 VGND VGND VPWR VPWR sky130_fd_sc_hd__decap_3
XFILLER_75_181 VGND VGND VPWR VPWR sky130_fd_sc_hd__decap_3
XFILLER_76_693 VGND VGND VPWR VPWR sky130_fd_sc_hd__decap_3
XFILLER_82_118 VGND VGND VPWR VPWR sky130_fd_sc_hd__decap_3
XFILLER_36_557 VGND VGND VPWR VPWR sky130_fd_sc_hd__fill_2
XFILLER_51_505 VGND VGND VPWR VPWR sky130_fd_sc_hd__decap_3
XFILLER_84_91 VGND VGND VPWR VPWR sky130_fd_sc_hd__decap_3
XFILLER_91_641 VGND VGND VPWR VPWR sky130_fd_sc_hd__decap_3
Xplace321 _5660_/A VGND VGND VPWR VPWR _3629_/A sky130_fd_sc_hd__buf_2
XFILLER_23_218 VGND VGND VPWR VPWR sky130_fd_sc_hd__decap_3
XFILLER_63_387 VGND VGND VPWR VPWR sky130_fd_sc_hd__decap_3
XFILLER_90_173 VGND VGND VPWR VPWR sky130_fd_sc_hd__fill_2
XFILLER_91_685 VGND VGND VPWR VPWR sky130_fd_sc_hd__decap_3
Xplace354 _3651_/Y VGND VGND VPWR VPWR _3879_/B1 sky130_fd_sc_hd__buf_2
Xplace343 _3889_/B1 VGND VGND VPWR VPWR _5660_/B sky130_fd_sc_hd__buf_2
Xplace332 _3926_/A2 VGND VGND VPWR VPWR _3760_/A2 sky130_fd_sc_hd__buf_2
X_6730_ clkload5/A _6730_/D VGND VGND VPWR VPWR _6730_/Q sky130_fd_sc_hd__dfxtp_2
X_4991_ _5004_/A _5004_/B _4988_/A VGND VGND VPWR VPWR _4991_/Y sky130_fd_sc_hd__a21oi_2
Xplace398 _5114_/A VGND VGND VPWR VPWR _4970_/A1 sky130_fd_sc_hd__buf_2
Xplace387 _4333_/A2 VGND VGND VPWR VPWR _4351_/B1 sky130_fd_sc_hd__buf_2
Xplace376 _4356_/A2 VGND VGND VPWR VPWR _4422_/A2 sky130_fd_sc_hd__buf_2
Xplace365 _3534_/Y VGND VGND VPWR VPWR _5071_/A sky130_fd_sc_hd__buf_2
XTAP_TAPCELL_ROW_102_1536 VGND VPWR sky130_fd_sc_hd__tapvpwrvgnd_1
XFILLER_31_240 VGND VGND VPWR VPWR sky130_fd_sc_hd__decap_3
X_6661_ _6662_/A VGND VGND VPWR VPWR _6661_/Y sky130_fd_sc_hd__inv_2
X_3873_ _3733_/X _3870_/X _3872_/X _3629_/A VGND VGND VPWR VPWR _3874_/B sky130_fd_sc_hd__a22o_2
X_6592_ _6624_/A VGND VGND VPWR VPWR _6592_/Y sky130_fd_sc_hd__inv_2
XTAP_TAPCELL_ROW_42_780 VGND VPWR sky130_fd_sc_hd__tapvpwrvgnd_1
XFILLER_8_480 VGND VGND VPWR VPWR sky130_fd_sc_hd__decap_3
XFILLER_105_518 VGND VGND VPWR VPWR sky130_fd_sc_hd__decap_3
X_7213_ _7374_/CLK _7213_/D _6493_/Y VGND VGND VPWR VPWR _7213_/Q sky130_fd_sc_hd__dfrtp_2
X_4425_ _4425_/A _4649_/B _4425_/C VGND VGND VPWR VPWR _4426_/B sky130_fd_sc_hd__and3_2
X_7144_ _7374_/CLK _7144_/D _6424_/Y VGND VGND VPWR VPWR _7144_/Q sky130_fd_sc_hd__dfrtp_2
X_4356_ _7012_/Q _4356_/A2 _4272_/B _7353_/Q _4355_/X VGND VGND VPWR VPWR _4356_/X
+ sky130_fd_sc_hd__a221o_2
XTAP_TAPCELL_ROW_113_1676 VGND VPWR sky130_fd_sc_hd__tapvpwrvgnd_1
XTAP_TAPCELL_ROW_113_1665 VGND VPWR sky130_fd_sc_hd__tapvpwrvgnd_1
XFILLER_113_573 VGND VGND VPWR VPWR sky130_fd_sc_hd__decap_3
XFILLER_48_29 VGND VGND VPWR VPWR sky130_fd_sc_hd__decap_3
XFILLER_59_638 VGND VGND VPWR VPWR sky130_fd_sc_hd__decap_3
XFILLER_86_424 VGND VGND VPWR VPWR sky130_fd_sc_hd__decap_3
XFILLER_58_137 VGND VGND VPWR VPWR sky130_fd_sc_hd__decap_3
XFILLER_86_457 VGND VGND VPWR VPWR sky130_fd_sc_hd__decap_3
X_7075_ _7403_/CLK _7075_/D _6355_/Y VGND VGND VPWR VPWR _7075_/Q sky130_fd_sc_hd__dfrtp_2
X_4287_ _7286_/Q _5142_/S _4352_/B1 _7158_/Q VGND VGND VPWR VPWR _4288_/D sky130_fd_sc_hd__a22o_2
XFILLER_100_256 VGND VGND VPWR VPWR sky130_fd_sc_hd__decap_3
XFILLER_104_13 VGND VGND VPWR VPWR sky130_fd_sc_hd__decap_3
XFILLER_39_351 VGND VGND VPWR VPWR sky130_fd_sc_hd__decap_3
XFILLER_58_159 VGND VGND VPWR VPWR sky130_fd_sc_hd__decap_3
XFILLER_67_671 VGND VGND VPWR VPWR sky130_fd_sc_hd__fill_1
XFILLER_73_107 VGND VGND VPWR VPWR sky130_fd_sc_hd__decap_3
XFILLER_27_535 VGND VGND VPWR VPWR sky130_fd_sc_hd__decap_3
XFILLER_39_373 VGND VGND VPWR VPWR sky130_fd_sc_hd__decap_3
XFILLER_54_321 VGND VGND VPWR VPWR sky130_fd_sc_hd__fill_2
XFILLER_67_682 VGND VGND VPWR VPWR sky130_fd_sc_hd__decap_3
XTAP_TAPCELL_ROW_68_1111 VGND VPWR sky130_fd_sc_hd__tapvpwrvgnd_1
XFILLER_81_140 VGND VGND VPWR VPWR sky130_fd_sc_hd__decap_3
XFILLER_82_663 VGND VGND VPWR VPWR sky130_fd_sc_hd__decap_3
XFILLER_42_505 VGND VGND VPWR VPWR sky130_fd_sc_hd__decap_3
XFILLER_42_527 VGND VGND VPWR VPWR sky130_fd_sc_hd__decap_3
XFILLER_54_365 VGND VGND VPWR VPWR sky130_fd_sc_hd__decap_3
XFILLER_82_696 VGND VGND VPWR VPWR sky130_fd_sc_hd__decap_3
X_6928_ _6942_/CLK _6928_/D VGND VGND VPWR VPWR _6928_/Q sky130_fd_sc_hd__dfxtp_2
XFILLER_10_402 VGND VGND VPWR VPWR sky130_fd_sc_hd__decap_3
XFILLER_22_251 VGND VGND VPWR VPWR sky130_fd_sc_hd__fill_1
X_6859_ _7189_/CLK _6859_/D VGND VGND VPWR VPWR _6859_/Q sky130_fd_sc_hd__dfxtp_2
XTAP_TAPCELL_ROW_12_408 VGND VPWR sky130_fd_sc_hd__tapvpwrvgnd_1
XFILLER_10_424 VGND VGND VPWR VPWR sky130_fd_sc_hd__decap_3
XFILLER_22_262 VGND VGND VPWR VPWR sky130_fd_sc_hd__decap_3
XFILLER_13_54 VGND VGND VPWR VPWR sky130_fd_sc_hd__fill_2
XTAP_TAPCELL_ROW_79_1251 VGND VPWR sky130_fd_sc_hd__tapvpwrvgnd_1
XTAP_TAPCELL_ROW_79_1240 VGND VPWR sky130_fd_sc_hd__tapvpwrvgnd_1
XFILLER_108_389 VGND VGND VPWR VPWR sky130_fd_sc_hd__decap_3
XFILLER_2_601 VGND VGND VPWR VPWR sky130_fd_sc_hd__decap_3
XFILLER_2_634 VGND VGND VPWR VPWR sky130_fd_sc_hd__decap_3
XFILLER_2_645 VGND VGND VPWR VPWR sky130_fd_sc_hd__decap_3
XFILLER_8_3 VGND VGND VPWR VPWR sky130_fd_sc_hd__fill_2
XFILLER_104_573 VGND VGND VPWR VPWR sky130_fd_sc_hd__decap_3
XFILLER_2_678 VGND VGND VPWR VPWR sky130_fd_sc_hd__decap_3
XFILLER_77_402 VGND VGND VPWR VPWR sky130_fd_sc_hd__decap_3
XFILLER_89_251 VGND VGND VPWR VPWR sky130_fd_sc_hd__fill_1
XFILLER_89_262 VGND VGND VPWR VPWR sky130_fd_sc_hd__decap_3
XFILLER_104_595 VGND VGND VPWR VPWR sky130_fd_sc_hd__decap_3
XFILLER_49_148 VGND VGND VPWR VPWR sky130_fd_sc_hd__decap_3
XFILLER_77_435 VGND VGND VPWR VPWR sky130_fd_sc_hd__decap_3
XFILLER_89_295 VGND VGND VPWR VPWR sky130_fd_sc_hd__decap_3
XFILLER_49_159 VGND VGND VPWR VPWR sky130_fd_sc_hd__decap_3
XFILLER_58_660 VGND VGND VPWR VPWR sky130_fd_sc_hd__decap_3
XFILLER_64_107 VGND VGND VPWR VPWR sky130_fd_sc_hd__decap_3
XFILLER_77_479 VGND VGND VPWR VPWR sky130_fd_sc_hd__decap_3
XFILLER_18_513 VGND VGND VPWR VPWR sky130_fd_sc_hd__decap_3
XFILLER_58_693 VGND VGND VPWR VPWR sky130_fd_sc_hd__decap_3
XFILLER_64_129 VGND VGND VPWR VPWR sky130_fd_sc_hd__decap_3
XFILLER_92_438 VGND VGND VPWR VPWR sky130_fd_sc_hd__decap_3
XFILLER_45_343 VGND VGND VPWR VPWR sky130_fd_sc_hd__decap_3
XFILLER_73_641 VGND VGND VPWR VPWR sky130_fd_sc_hd__decap_3
Xhold1180 _7021_/Q VGND VGND VPWR VPWR _5613_/A sky130_fd_sc_hd__dlygate4sd3_1
Xhold1191 _7229_/Q VGND VGND VPWR VPWR _5198_/A sky130_fd_sc_hd__dlygate4sd3_1
XFILLER_33_505 VGND VGND VPWR VPWR sky130_fd_sc_hd__decap_3
XFILLER_45_387 VGND VGND VPWR VPWR sky130_fd_sc_hd__decap_3
XFILLER_73_685 VGND VGND VPWR VPWR sky130_fd_sc_hd__decap_3
XFILLER_72_195 VGND VGND VPWR VPWR sky130_fd_sc_hd__fill_1
XFILLER_54_94 VGND VGND VPWR VPWR sky130_fd_sc_hd__decap_3
XFILLER_60_357 VGND VGND VPWR VPWR sky130_fd_sc_hd__decap_3
XFILLER_41_582 VGND VGND VPWR VPWR sky130_fd_sc_hd__decap_3
XFILLER_9_211 VGND VGND VPWR VPWR sky130_fd_sc_hd__decap_3
Xclkload14 _7345_/CLK VGND VGND VPWR VPWR clkload14/X sky130_fd_sc_hd__clkbuf_1
Xclkload25 _7396_/CLK VGND VGND VPWR VPWR clkload25/X sky130_fd_sc_hd__clkbuf_8
Xclkload36 _7374_/CLK VGND VGND VPWR VPWR clkload36/Y sky130_fd_sc_hd__clkinv_2
XFILLER_114_359 VGND VGND VPWR VPWR sky130_fd_sc_hd__fill_2
XFILLER_5_494 VGND VGND VPWR VPWR sky130_fd_sc_hd__decap_3
X_4210_ _4095_/A _4210_/B VGND VGND VPWR VPWR _4210_/X sky130_fd_sc_hd__and2b_2
X_5190_ _5190_/A _5198_/B VGND VGND VPWR VPWR _7233_/D sky130_fd_sc_hd__and2_2
XFILLER_95_232 VGND VGND VPWR VPWR sky130_fd_sc_hd__decap_3
X_4141_ _4141_/A _4141_/B VGND VGND VPWR VPWR _4142_/B sky130_fd_sc_hd__nor2_2
XFILLER_56_619 VGND VGND VPWR VPWR sky130_fd_sc_hd__decap_3
X_4072_ _7243_/Q _4430_/A2 _4459_/C1 _7179_/Q _4071_/X VGND VGND VPWR VPWR _4072_/X
+ sky130_fd_sc_hd__a221o_2
XFILLER_110_587 VGND VGND VPWR VPWR sky130_fd_sc_hd__fill_1
XFILLER_110_598 VGND VGND VPWR VPWR sky130_fd_sc_hd__decap_3
XFILLER_49_671 VGND VGND VPWR VPWR sky130_fd_sc_hd__fill_1
XFILLER_49_682 VGND VGND VPWR VPWR sky130_fd_sc_hd__decap_3
XFILLER_83_449 VGND VGND VPWR VPWR sky130_fd_sc_hd__decap_3
XFILLER_95_276 VGND VGND VPWR VPWR sky130_fd_sc_hd__decap_3
XFILLER_36_321 VGND VGND VPWR VPWR sky130_fd_sc_hd__decap_3
XFILLER_48_181 VGND VGND VPWR VPWR sky130_fd_sc_hd__decap_3
XFILLER_64_663 VGND VGND VPWR VPWR sky130_fd_sc_hd__decap_3
XTAP_TAPCELL_ROW_47_850 VGND VPWR sky130_fd_sc_hd__tapvpwrvgnd_1
XFILLER_51_313 VGND VGND VPWR VPWR sky130_fd_sc_hd__decap_3
XFILLER_63_140 VGND VGND VPWR VPWR sky130_fd_sc_hd__decap_3
XFILLER_63_151 VGND VGND VPWR VPWR sky130_fd_sc_hd__fill_1
XFILLER_64_696 VGND VGND VPWR VPWR sky130_fd_sc_hd__decap_3
XFILLER_17_590 VGND VGND VPWR VPWR sky130_fd_sc_hd__decap_3
XFILLER_63_195 VGND VGND VPWR VPWR sky130_fd_sc_hd__decap_3
X_4974_ _6993_/Q _4983_/B VGND VGND VPWR VPWR _4975_/B sky130_fd_sc_hd__xor2_2
X_6713_ _7086_/CLK _6713_/D VGND VGND VPWR VPWR _6713_/Q sky130_fd_sc_hd__dfxtp_2
X_3925_ _6687_/Q _3925_/A2 _3925_/B1 _6865_/Q VGND VGND VPWR VPWR _3925_/X sky130_fd_sc_hd__a22o_2
XTAP_TAPCELL_ROW_63_1041 VGND VPWR sky130_fd_sc_hd__tapvpwrvgnd_1
XFILLER_32_582 VGND VGND VPWR VPWR sky130_fd_sc_hd__decap_3
X_6644_ _6644_/A VGND VGND VPWR VPWR _6644_/Y sky130_fd_sc_hd__inv_2
XFILLER_109_109 VGND VGND VPWR VPWR sky130_fd_sc_hd__decap_3
Xclkload8 clkload8/A VGND VGND VPWR VPWR clkload8/X sky130_fd_sc_hd__clkbuf_1
X_3856_ _3845_/X _3855_/X _3991_/A VGND VGND VPWR VPWR _3856_/X sky130_fd_sc_hd__o21a_2
XFILLER_118_610 VGND VGND VPWR VPWR sky130_fd_sc_hd__decap_3
XFILLER_118_643 VGND VGND VPWR VPWR sky130_fd_sc_hd__fill_1
X_6575_ _6639_/A VGND VGND VPWR VPWR _6575_/Y sky130_fd_sc_hd__inv_2
X_3787_ _6739_/Q _3840_/A2 _3850_/B1 _6745_/Q _3786_/X VGND VGND VPWR VPWR _3787_/X
+ sky130_fd_sc_hd__a221o_2
XFILLER_118_654 VGND VGND VPWR VPWR sky130_fd_sc_hd__decap_3
XFILLER_105_304 VGND VGND VPWR VPWR sky130_fd_sc_hd__decap_3
XFILLER_117_175 VGND VGND VPWR VPWR sky130_fd_sc_hd__decap_3
XFILLER_118_687 VGND VGND VPWR VPWR sky130_fd_sc_hd__decap_3
XFILLER_105_337 VGND VGND VPWR VPWR sky130_fd_sc_hd__decap_3
XFILLER_59_28 VGND VGND VPWR VPWR sky130_fd_sc_hd__decap_3
X_4408_ _7024_/Q _4437_/A2 _4404_/X _4407_/X VGND VGND VPWR VPWR _4409_/B sky130_fd_sc_hd__a211o_2
XFILLER_115_12 VGND VGND VPWR VPWR sky130_fd_sc_hd__decap_3
XFILLER_59_402 VGND VGND VPWR VPWR sky130_fd_sc_hd__decap_3
XFILLER_87_700 VGND VGND VPWR VPWR sky130_fd_sc_hd__decap_3
Xoutput596 _5654_/Y VGND VGND VPWR VPWR alu_result_out[31] sky130_fd_sc_hd__clkdlybuf4s25_1
Xoutput585 _5656_/B VGND VGND VPWR VPWR alu_result_out[21] sky130_fd_sc_hd__clkdlybuf4s25_1
Xoutput574 _5662_/B VGND VGND VPWR VPWR alu_result_out[11] sky130_fd_sc_hd__clkdlybuf4s25_1
X_5388_ _5388_/A0 _4913_/X _5390_/S VGND VGND VPWR VPWR _7139_/D sky130_fd_sc_hd__mux2_2
XTAP_TAPCELL_ROW_74_1181 VGND VPWR sky130_fd_sc_hd__tapvpwrvgnd_1
XFILLER_101_521 VGND VGND VPWR VPWR sky130_fd_sc_hd__decap_3
XFILLER_115_45 VGND VGND VPWR VPWR sky130_fd_sc_hd__decap_3
XFILLER_59_424 VGND VGND VPWR VPWR sky130_fd_sc_hd__decap_3
XFILLER_86_221 VGND VGND VPWR VPWR sky130_fd_sc_hd__fill_1
X_7127_ _7357_/CLK _7127_/D _6407_/Y VGND VGND VPWR VPWR _7127_/Q sky130_fd_sc_hd__dfrtp_2
X_4339_ _7287_/Q _4300_/B _4339_/B1 _7159_/Q VGND VGND VPWR VPWR _4339_/X sky130_fd_sc_hd__a22o_2
XFILLER_115_78 VGND VGND VPWR VPWR sky130_fd_sc_hd__decap_3
X_7058_ _7344_/CLK _7058_/D _6338_/Y VGND VGND VPWR VPWR _7058_/Q sky130_fd_sc_hd__dfstp_2
XFILLER_74_416 VGND VGND VPWR VPWR sky130_fd_sc_hd__decap_3
XFILLER_86_276 VGND VGND VPWR VPWR sky130_fd_sc_hd__decap_3
XFILLER_27_321 VGND VGND VPWR VPWR sky130_fd_sc_hd__decap_3
XFILLER_27_343 VGND VGND VPWR VPWR sky130_fd_sc_hd__decap_3
XFILLER_39_192 VGND VGND VPWR VPWR sky130_fd_sc_hd__decap_3
XFILLER_55_641 VGND VGND VPWR VPWR sky130_fd_sc_hd__decap_3
XFILLER_67_490 VGND VGND VPWR VPWR sky130_fd_sc_hd__decap_3
XFILLER_15_505 VGND VGND VPWR VPWR sky130_fd_sc_hd__decap_3
XFILLER_27_365 VGND VGND VPWR VPWR sky130_fd_sc_hd__decap_3
XFILLER_42_302 VGND VGND VPWR VPWR sky130_fd_sc_hd__decap_3
XFILLER_54_162 VGND VGND VPWR VPWR sky130_fd_sc_hd__decap_3
XFILLER_55_685 VGND VGND VPWR VPWR sky130_fd_sc_hd__decap_3
XFILLER_82_471 VGND VGND VPWR VPWR sky130_fd_sc_hd__decap_3
XFILLER_42_324 VGND VGND VPWR VPWR sky130_fd_sc_hd__decap_3
XFILLER_54_195 VGND VGND VPWR VPWR sky130_fd_sc_hd__fill_1
XFILLER_70_622 VGND VGND VPWR VPWR sky130_fd_sc_hd__decap_3
XFILLER_91_37 VGND VGND VPWR VPWR sky130_fd_sc_hd__decap_3
XFILLER_11_700 VGND VGND VPWR VPWR sky130_fd_sc_hd__decap_3
XFILLER_42_379 VGND VGND VPWR VPWR sky130_fd_sc_hd__decap_3
XFILLER_70_666 VGND VGND VPWR VPWR sky130_fd_sc_hd__decap_3
XTAP_TAPCELL_ROW_25_566 VGND VPWR sky130_fd_sc_hd__tapvpwrvgnd_1
XFILLER_70_699 VGND VGND VPWR VPWR sky130_fd_sc_hd__fill_1
XFILLER_109_632 VGND VGND VPWR VPWR sky130_fd_sc_hd__decap_3
XFILLER_109_665 VGND VGND VPWR VPWR sky130_fd_sc_hd__decap_3
XFILLER_109_676 VGND VGND VPWR VPWR sky130_fd_sc_hd__decap_3
XFILLER_108_153 VGND VGND VPWR VPWR sky130_fd_sc_hd__decap_3
XFILLER_108_175 VGND VGND VPWR VPWR sky130_fd_sc_hd__decap_3
XFILLER_40_85 VGND VGND VPWR VPWR sky130_fd_sc_hd__decap_3
XFILLER_108_197 VGND VGND VPWR VPWR sky130_fd_sc_hd__decap_3
XFILLER_104_392 VGND VGND VPWR VPWR sky130_fd_sc_hd__decap_3
XFILLER_2_486 VGND VGND VPWR VPWR sky130_fd_sc_hd__decap_3
XFILLER_38_619 VGND VGND VPWR VPWR sky130_fd_sc_hd__decap_3
XFILLER_93_703 VGND VGND VPWR VPWR sky130_fd_sc_hd__decap_3
XFILLER_1_57 VGND VGND VPWR VPWR sky130_fd_sc_hd__decap_3
XFILLER_65_449 VGND VGND VPWR VPWR sky130_fd_sc_hd__decap_3
XFILLER_18_365 VGND VGND VPWR VPWR sky130_fd_sc_hd__decap_3
XFILLER_33_302 VGND VGND VPWR VPWR sky130_fd_sc_hd__decap_3
XFILLER_46_663 VGND VGND VPWR VPWR sky130_fd_sc_hd__decap_3
XFILLER_61_611 VGND VGND VPWR VPWR sky130_fd_sc_hd__decap_3
XFILLER_80_419 VGND VGND VPWR VPWR sky130_fd_sc_hd__fill_1
XFILLER_92_268 VGND VGND VPWR VPWR sky130_fd_sc_hd__fill_2
XFILLER_18_398 VGND VGND VPWR VPWR sky130_fd_sc_hd__decap_3
XFILLER_33_335 VGND VGND VPWR VPWR sky130_fd_sc_hd__fill_1
XFILLER_46_696 VGND VGND VPWR VPWR sky130_fd_sc_hd__decap_3
XFILLER_61_644 VGND VGND VPWR VPWR sky130_fd_sc_hd__decap_3
XFILLER_73_482 VGND VGND VPWR VPWR sky130_fd_sc_hd__decap_3
XFILLER_21_508 VGND VGND VPWR VPWR sky130_fd_sc_hd__fill_2
XFILLER_61_688 VGND VGND VPWR VPWR sky130_fd_sc_hd__decap_3
XFILLER_14_582 VGND VGND VPWR VPWR sky130_fd_sc_hd__decap_3
XFILLER_60_176 VGND VGND VPWR VPWR sky130_fd_sc_hd__decap_3
X_3710_ _3710_/A1 _4832_/A _3709_/X VGND VGND VPWR VPWR _7399_/D sky130_fd_sc_hd__o21a_2
XFILLER_81_92 VGND VGND VPWR VPWR sky130_fd_sc_hd__decap_3
X_4690_ _7005_/Q _4690_/B VGND VGND VPWR VPWR _4757_/A sky130_fd_sc_hd__and2_2
XFILLER_119_429 VGND VGND VPWR VPWR sky130_fd_sc_hd__decap_3
XFILLER_60_3 VGND VGND VPWR VPWR sky130_fd_sc_hd__decap_3
X_6360_ _6683_/A VGND VGND VPWR VPWR _6360_/Y sky130_fd_sc_hd__inv_2
X_3572_ _4295_/B _3607_/B VGND VGND VPWR VPWR _4292_/A sky130_fd_sc_hd__xnor2_2
XFILLER_115_602 VGND VGND VPWR VPWR sky130_fd_sc_hd__decap_3
XFILLER_115_635 VGND VGND VPWR VPWR sky130_fd_sc_hd__decap_3
XFILLER_115_668 VGND VGND VPWR VPWR sky130_fd_sc_hd__decap_3
X_6291_ _6626_/A VGND VGND VPWR VPWR _6291_/Y sky130_fd_sc_hd__inv_2
XFILLER_102_307 VGND VGND VPWR VPWR sky130_fd_sc_hd__fill_1
XFILLER_102_318 VGND VGND VPWR VPWR sky130_fd_sc_hd__decap_3
XFILLER_115_679 VGND VGND VPWR VPWR sky130_fd_sc_hd__decap_3
XFILLER_69_700 VGND VGND VPWR VPWR sky130_fd_sc_hd__decap_3
XFILLER_68_221 VGND VGND VPWR VPWR sky130_fd_sc_hd__decap_3
X_5173_ _5173_/A _5198_/B VGND VGND VPWR VPWR _7241_/D sky130_fd_sc_hd__and2_2
XTAP_TAPCELL_ROW_110_1635 VGND VPWR sky130_fd_sc_hd__tapvpwrvgnd_1
XFILLER_68_265 VGND VGND VPWR VPWR sky130_fd_sc_hd__decap_3
X_4124_ _4117_/Y _4124_/B VGND VGND VPWR VPWR _4126_/A sky130_fd_sc_hd__and2b_2
XFILLER_110_362 VGND VGND VPWR VPWR sky130_fd_sc_hd__fill_2
XFILLER_28_118 VGND VGND VPWR VPWR sky130_fd_sc_hd__decap_3
XFILLER_56_416 VGND VGND VPWR VPWR sky130_fd_sc_hd__decap_3
XFILLER_56_427 VGND VGND VPWR VPWR sky130_fd_sc_hd__decap_3
XFILLER_83_202 VGND VGND VPWR VPWR sky130_fd_sc_hd__decap_3
XFILLER_37_641 VGND VGND VPWR VPWR sky130_fd_sc_hd__decap_3
XFILLER_83_257 VGND VGND VPWR VPWR sky130_fd_sc_hd__decap_3
X_4055_ _4055_/A _4658_/A VGND VGND VPWR VPWR _4720_/A sky130_fd_sc_hd__nor2b_2
XFILLER_37_685 VGND VGND VPWR VPWR sky130_fd_sc_hd__decap_3
XFILLER_83_279 VGND VGND VPWR VPWR sky130_fd_sc_hd__fill_1
XFILLER_24_335 VGND VGND VPWR VPWR sky130_fd_sc_hd__decap_3
XFILLER_36_173 VGND VGND VPWR VPWR sky130_fd_sc_hd__decap_3
XFILLER_36_195 VGND VGND VPWR VPWR sky130_fd_sc_hd__fill_1
XFILLER_52_622 VGND VGND VPWR VPWR sky130_fd_sc_hd__decap_3
XFILLER_12_508 VGND VGND VPWR VPWR sky130_fd_sc_hd__fill_1
XFILLER_24_368 VGND VGND VPWR VPWR sky130_fd_sc_hd__decap_3
XFILLER_51_143 VGND VGND VPWR VPWR sky130_fd_sc_hd__decap_3
XFILLER_52_666 VGND VGND VPWR VPWR sky130_fd_sc_hd__decap_3
XFILLER_51_187 VGND VGND VPWR VPWR sky130_fd_sc_hd__decap_3
XFILLER_52_699 VGND VGND VPWR VPWR sky130_fd_sc_hd__fill_1
XFILLER_61_29 VGND VGND VPWR VPWR sky130_fd_sc_hd__decap_3
X_4957_ _4982_/B _5009_/A _6992_/Q VGND VGND VPWR VPWR _4983_/B sky130_fd_sc_hd__o21ai_2
XFILLER_20_530 VGND VGND VPWR VPWR sky130_fd_sc_hd__fill_2
X_4888_ _4888_/A _4888_/B VGND VGND VPWR VPWR _4889_/B sky130_fd_sc_hd__or2_2
X_3908_ _3728_/B _3907_/X _3991_/A VGND VGND VPWR VPWR _3908_/X sky130_fd_sc_hd__o21a_2
XTAP_TAPCELL_ROW_22_536 VGND VPWR sky130_fd_sc_hd__tapvpwrvgnd_1
XFILLER_20_574 VGND VGND VPWR VPWR sky130_fd_sc_hd__decap_3
X_6627_ _6627_/A VGND VGND VPWR VPWR _6627_/Y sky130_fd_sc_hd__inv_2
X_3839_ _3746_/X _3836_/X _3838_/X _3733_/X VGND VGND VPWR VPWR _3845_/A sky130_fd_sc_hd__a22o_2
XTAP_TAPCELL_ROW_50_889 VGND VPWR sky130_fd_sc_hd__tapvpwrvgnd_1
XTAP_TAPCELL_ROW_50_878 VGND VPWR sky130_fd_sc_hd__tapvpwrvgnd_1
XFILLER_4_707 VGND VGND VPWR VPWR sky130_fd_sc_hd__decap_3
X_6558_ _6652_/A VGND VGND VPWR VPWR _6558_/Y sky130_fd_sc_hd__inv_2
XFILLER_106_613 VGND VGND VPWR VPWR sky130_fd_sc_hd__decap_3
XTAP_TAPCELL_ROW_76_1210 VGND VPWR sky130_fd_sc_hd__tapvpwrvgnd_1
XFILLER_106_657 VGND VGND VPWR VPWR sky130_fd_sc_hd__decap_3
XFILLER_3_228 VGND VGND VPWR VPWR sky130_fd_sc_hd__decap_3
X_6489_ _6554_/A VGND VGND VPWR VPWR _6489_/Y sky130_fd_sc_hd__inv_2
XFILLER_105_156 VGND VGND VPWR VPWR sky130_fd_sc_hd__decap_3
XFILLER_105_178 VGND VGND VPWR VPWR sky130_fd_sc_hd__decap_3
XFILLER_79_508 VGND VGND VPWR VPWR sky130_fd_sc_hd__decap_3
XFILLER_114_690 VGND VGND VPWR VPWR sky130_fd_sc_hd__decap_3
XFILLER_101_340 VGND VGND VPWR VPWR sky130_fd_sc_hd__decap_3
XFILLER_59_232 VGND VGND VPWR VPWR sky130_fd_sc_hd__fill_1
XFILLER_75_703 VGND VGND VPWR VPWR sky130_fd_sc_hd__decap_3
XFILLER_19_86 VGND VGND VPWR VPWR sky130_fd_sc_hd__decap_3
XFILLER_47_449 VGND VGND VPWR VPWR sky130_fd_sc_hd__decap_3
Xclkbuf_leaf_39_clk clkbuf_3_2__f_clk/X VGND VGND VPWR VPWR _6983_/CLK sky130_fd_sc_hd__clkbuf_16
XFILLER_15_302 VGND VGND VPWR VPWR sky130_fd_sc_hd__decap_3
XFILLER_27_140 VGND VGND VPWR VPWR sky130_fd_sc_hd__decap_3
XFILLER_28_663 VGND VGND VPWR VPWR sky130_fd_sc_hd__decap_3
XFILLER_74_279 VGND VGND VPWR VPWR sky130_fd_sc_hd__decap_3
XTAP_TAPCELL_ROW_87_1350 VGND VPWR sky130_fd_sc_hd__tapvpwrvgnd_1
XTAP_TAPCELL_ROW_58_989 VGND VPWR sky130_fd_sc_hd__tapvpwrvgnd_1
XTAP_TAPCELL_ROW_58_978 VGND VPWR sky130_fd_sc_hd__tapvpwrvgnd_1
XTAP_TAPCELL_ROW_2_283 VGND VPWR sky130_fd_sc_hd__tapvpwrvgnd_1
XFILLER_27_184 VGND VGND VPWR VPWR sky130_fd_sc_hd__decap_3
XFILLER_27_195 VGND VGND VPWR VPWR sky130_fd_sc_hd__decap_3
XFILLER_28_696 VGND VGND VPWR VPWR sky130_fd_sc_hd__decap_3
XFILLER_35_52 VGND VGND VPWR VPWR sky130_fd_sc_hd__decap_3
XFILLER_43_644 VGND VGND VPWR VPWR sky130_fd_sc_hd__decap_3
XFILLER_55_493 VGND VGND VPWR VPWR sky130_fd_sc_hd__decap_3
XFILLER_70_430 VGND VGND VPWR VPWR sky130_fd_sc_hd__decap_3
XFILLER_15_368 VGND VGND VPWR VPWR sky130_fd_sc_hd__decap_3
XFILLER_35_63 VGND VGND VPWR VPWR sky130_fd_sc_hd__decap_3
XPHY_EDGE_ROW_106_Left_226 VGND VGND VPWR VPWR sky130_fd_sc_hd__decap_3
XFILLER_30_316 VGND VGND VPWR VPWR sky130_fd_sc_hd__fill_1
XFILLER_42_187 VGND VGND VPWR VPWR sky130_fd_sc_hd__decap_3
XFILLER_43_688 VGND VGND VPWR VPWR sky130_fd_sc_hd__decap_3
XFILLER_70_485 VGND VGND VPWR VPWR sky130_fd_sc_hd__decap_3
XFILLER_11_541 VGND VGND VPWR VPWR sky130_fd_sc_hd__decap_3
XFILLER_11_585 VGND VGND VPWR VPWR sky130_fd_sc_hd__decap_3
XFILLER_7_545 VGND VGND VPWR VPWR sky130_fd_sc_hd__decap_3
XFILLER_7_567 VGND VGND VPWR VPWR sky130_fd_sc_hd__decap_3
XPHY_EDGE_ROW_115_Left_235 VGND VGND VPWR VPWR sky130_fd_sc_hd__decap_3
XFILLER_112_616 VGND VGND VPWR VPWR sky130_fd_sc_hd__decap_3
XFILLER_2_250 VGND VGND VPWR VPWR sky130_fd_sc_hd__fill_2
XFILLER_111_104 VGND VGND VPWR VPWR sky130_fd_sc_hd__decap_3
XFILLER_111_159 VGND VGND VPWR VPWR sky130_fd_sc_hd__decap_3
XFILLER_78_574 VGND VGND VPWR VPWR sky130_fd_sc_hd__decap_3
XFILLER_93_500 VGND VGND VPWR VPWR sky130_fd_sc_hd__fill_1
XFILLER_19_641 VGND VGND VPWR VPWR sky130_fd_sc_hd__decap_3
XFILLER_65_246 VGND VGND VPWR VPWR sky130_fd_sc_hd__decap_3
XFILLER_76_81 VGND VGND VPWR VPWR sky130_fd_sc_hd__decap_3
XFILLER_81_706 VGND VGND VPWR VPWR sky130_fd_sc_hd__decap_3
XFILLER_19_685 VGND VGND VPWR VPWR sky130_fd_sc_hd__decap_3
XFILLER_53_408 VGND VGND VPWR VPWR sky130_fd_sc_hd__decap_3
XFILLER_80_216 VGND VGND VPWR VPWR sky130_fd_sc_hd__decap_3
XFILLER_93_588 VGND VGND VPWR VPWR sky130_fd_sc_hd__decap_3
XFILLER_18_173 VGND VGND VPWR VPWR sky130_fd_sc_hd__decap_3
XFILLER_34_622 VGND VGND VPWR VPWR sky130_fd_sc_hd__decap_3
XFILLER_46_471 VGND VGND VPWR VPWR sky130_fd_sc_hd__decap_3
XFILLER_80_249 VGND VGND VPWR VPWR sky130_fd_sc_hd__decap_3
XFILLER_34_666 VGND VGND VPWR VPWR sky130_fd_sc_hd__decap_3
XFILLER_61_463 VGND VGND VPWR VPWR sky130_fd_sc_hd__decap_3
XFILLER_73_290 VGND VGND VPWR VPWR sky130_fd_sc_hd__fill_2
X_4811_ _4652_/B _4811_/B _4811_/C VGND VGND VPWR VPWR _4811_/X sky130_fd_sc_hd__and3b_2
XFILLER_21_316 VGND VGND VPWR VPWR sky130_fd_sc_hd__fill_2
XFILLER_33_187 VGND VGND VPWR VPWR sky130_fd_sc_hd__decap_3
XFILLER_34_699 VGND VGND VPWR VPWR sky130_fd_sc_hd__fill_1
XFILLER_61_474 VGND VGND VPWR VPWR sky130_fd_sc_hd__decap_3
XFILLER_61_496 VGND VGND VPWR VPWR sky130_fd_sc_hd__decap_3
XFILLER_92_91 VGND VGND VPWR VPWR sky130_fd_sc_hd__decap_3
XFILLER_21_349 VGND VGND VPWR VPWR sky130_fd_sc_hd__fill_1
XFILLER_33_198 VGND VGND VPWR VPWR sky130_fd_sc_hd__decap_3
X_4742_ _4745_/A _4081_/X _4454_/X _4969_/B VGND VGND VPWR VPWR _4742_/Y sky130_fd_sc_hd__o211ai_2
XTAP_TAPCELL_ROW_60_1011 VGND VPWR sky130_fd_sc_hd__tapvpwrvgnd_1
XFILLER_119_237 VGND VGND VPWR VPWR sky130_fd_sc_hd__fill_2
X_4673_ _4982_/B _4673_/B VGND VGND VPWR VPWR _4680_/A sky130_fd_sc_hd__or2_2
XFILLER_119_259 VGND VGND VPWR VPWR sky130_fd_sc_hd__fill_1
X_6412_ _6638_/A VGND VGND VPWR VPWR _6412_/Y sky130_fd_sc_hd__inv_2
X_3624_ _5114_/A _3600_/A _4614_/C _3635_/B VGND VGND VPWR VPWR _3624_/X sky130_fd_sc_hd__a22o_2
X_7392_ _7396_/CLK _7392_/D _6672_/Y VGND VGND VPWR VPWR _7392_/Q sky130_fd_sc_hd__dfrtp_2
X_6343_ _6664_/A VGND VGND VPWR VPWR _6343_/Y sky130_fd_sc_hd__inv_2
X_3555_ _7285_/Q _4528_/B _4339_/B1 _7157_/Q VGND VGND VPWR VPWR _3556_/C sky130_fd_sc_hd__a22o_2
XFILLER_115_454 VGND VGND VPWR VPWR sky130_fd_sc_hd__decap_3
X_6274_ _6676_/A VGND VGND VPWR VPWR _6274_/Y sky130_fd_sc_hd__inv_2
X_3486_ _3502_/A _3502_/B _3485_/C VGND VGND VPWR VPWR _5144_/B sky130_fd_sc_hd__o21ai_2
XFILLER_102_115 VGND VGND VPWR VPWR sky130_fd_sc_hd__decap_3
XFILLER_103_638 VGND VGND VPWR VPWR sky130_fd_sc_hd__decap_3
XFILLER_88_338 VGND VGND VPWR VPWR sky130_fd_sc_hd__decap_3
X_5225_ _5225_/A _5225_/B VGND VGND VPWR VPWR _7216_/D sky130_fd_sc_hd__and2_2
XFILLER_57_703 VGND VGND VPWR VPWR sky130_fd_sc_hd__decap_3
XTAP_TAPCELL_ROW_71_1151 VGND VPWR sky130_fd_sc_hd__tapvpwrvgnd_1
XTAP_TAPCELL_ROW_71_1140 VGND VPWR sky130_fd_sc_hd__tapvpwrvgnd_1
XFILLER_111_671 VGND VGND VPWR VPWR sky130_fd_sc_hd__fill_1
XFILLER_111_682 VGND VGND VPWR VPWR sky130_fd_sc_hd__decap_3
XFILLER_29_405 VGND VGND VPWR VPWR sky130_fd_sc_hd__decap_3
XFILLER_56_29 VGND VGND VPWR VPWR sky130_fd_sc_hd__decap_3
XFILLER_96_371 VGND VGND VPWR VPWR sky130_fd_sc_hd__decap_3
X_5156_ _7010_/D _5155_/X _5156_/S VGND VGND VPWR VPWR _5156_/X sky130_fd_sc_hd__mux2_2
XFILLER_110_192 VGND VGND VPWR VPWR sky130_fd_sc_hd__decap_3
XFILLER_84_533 VGND VGND VPWR VPWR sky130_fd_sc_hd__fill_1
X_5087_ _5101_/B _5100_/B _5086_/A _4365_/X VGND VGND VPWR VPWR _5087_/Y sky130_fd_sc_hd__a211oi_2
X_4107_ _7301_/Q _5080_/S _4417_/B1 _7109_/Q _4106_/X VGND VGND VPWR VPWR _4107_/X
+ sky130_fd_sc_hd__a221o_2
XFILLER_112_24 VGND VGND VPWR VPWR sky130_fd_sc_hd__decap_3
XFILLER_71_205 VGND VGND VPWR VPWR sky130_fd_sc_hd__decap_3
X_4038_ _4039_/A _4458_/A VGND VGND VPWR VPWR _4608_/B sky130_fd_sc_hd__nor2_2
XFILLER_112_35 VGND VGND VPWR VPWR sky130_fd_sc_hd__decap_3
XFILLER_112_68 VGND VGND VPWR VPWR sky130_fd_sc_hd__decap_3
XFILLER_25_644 VGND VGND VPWR VPWR sky130_fd_sc_hd__decap_3
XTAP_TAPCELL_ROW_55_948 VGND VPWR sky130_fd_sc_hd__tapvpwrvgnd_1
XFILLER_24_132 VGND VGND VPWR VPWR sky130_fd_sc_hd__decap_3
XFILLER_12_305 VGND VGND VPWR VPWR sky130_fd_sc_hd__decap_3
XFILLER_24_165 VGND VGND VPWR VPWR sky130_fd_sc_hd__decap_3
XFILLER_25_688 VGND VGND VPWR VPWR sky130_fd_sc_hd__decap_3
XFILLER_40_625 VGND VGND VPWR VPWR sky130_fd_sc_hd__decap_3
XFILLER_40_669 VGND VGND VPWR VPWR sky130_fd_sc_hd__decap_3
XFILLER_8_309 VGND VGND VPWR VPWR sky130_fd_sc_hd__decap_3
XTAP_TAPCELL_ROW_82_1280 VGND VPWR sky130_fd_sc_hd__tapvpwrvgnd_1
XTAP_TAPCELL_ROW_35_694 VGND VPWR sky130_fd_sc_hd__tapvpwrvgnd_1
XFILLER_20_371 VGND VGND VPWR VPWR sky130_fd_sc_hd__decap_3
XFILLER_21_43 VGND VGND VPWR VPWR sky130_fd_sc_hd__decap_3
XFILLER_4_504 VGND VGND VPWR VPWR sky130_fd_sc_hd__decap_3
XFILLER_4_515 VGND VGND VPWR VPWR sky130_fd_sc_hd__decap_3
XFILLER_106_410 VGND VGND VPWR VPWR sky130_fd_sc_hd__decap_3
XFILLER_106_421 VGND VGND VPWR VPWR sky130_fd_sc_hd__decap_3
XFILLER_108_3 VGND VGND VPWR VPWR sky130_fd_sc_hd__decap_3
XFILLER_4_548 VGND VGND VPWR VPWR sky130_fd_sc_hd__decap_3
XFILLER_106_454 VGND VGND VPWR VPWR sky130_fd_sc_hd__decap_3
XTAP_TAPCELL_ROW_7_342 VGND VPWR sky130_fd_sc_hd__tapvpwrvgnd_1
XFILLER_102_660 VGND VGND VPWR VPWR sky130_fd_sc_hd__decap_3
XFILLER_47_202 VGND VGND VPWR VPWR sky130_fd_sc_hd__decap_3
XFILLER_101_181 VGND VGND VPWR VPWR sky130_fd_sc_hd__decap_3
XFILLER_102_693 VGND VGND VPWR VPWR sky130_fd_sc_hd__decap_3
XFILLER_47_246 VGND VGND VPWR VPWR sky130_fd_sc_hd__decap_3
XFILLER_75_555 VGND VGND VPWR VPWR sky130_fd_sc_hd__decap_3
XFILLER_87_393 VGND VGND VPWR VPWR sky130_fd_sc_hd__decap_3
XFILLER_47_279 VGND VGND VPWR VPWR sky130_fd_sc_hd__fill_1
XFILLER_63_706 VGND VGND VPWR VPWR sky130_fd_sc_hd__decap_3
XFILLER_16_622 VGND VGND VPWR VPWR sky130_fd_sc_hd__decap_3
XFILLER_90_536 VGND VGND VPWR VPWR sky130_fd_sc_hd__fill_1
XFILLER_16_666 VGND VGND VPWR VPWR sky130_fd_sc_hd__decap_3
XFILLER_43_452 VGND VGND VPWR VPWR sky130_fd_sc_hd__decap_3
XFILLER_55_290 VGND VGND VPWR VPWR sky130_fd_sc_hd__decap_3
XFILLER_16_699 VGND VGND VPWR VPWR sky130_fd_sc_hd__fill_1
XFILLER_30_102 VGND VGND VPWR VPWR sky130_fd_sc_hd__fill_2
XFILLER_43_485 VGND VGND VPWR VPWR sky130_fd_sc_hd__decap_3
XFILLER_30_124 VGND VGND VPWR VPWR sky130_fd_sc_hd__decap_3
XFILLER_31_647 VGND VGND VPWR VPWR sky130_fd_sc_hd__decap_3
XFILLER_70_293 VGND VGND VPWR VPWR sky130_fd_sc_hd__decap_3
XFILLER_62_94 VGND VGND VPWR VPWR sky130_fd_sc_hd__fill_1
XFILLER_11_382 VGND VGND VPWR VPWR sky130_fd_sc_hd__decap_3
XFILLER_109_281 VGND VGND VPWR VPWR sky130_fd_sc_hd__decap_3
X_3340_ _3340_/A _3340_/B _3340_/C VGND VGND VPWR VPWR _5640_/B sky130_fd_sc_hd__and3_2
XFILLER_3_570 VGND VGND VPWR VPWR sky130_fd_sc_hd__decap_3
XFILLER_98_636 VGND VGND VPWR VPWR sky130_fd_sc_hd__decap_3
XFILLER_112_468 VGND VGND VPWR VPWR sky130_fd_sc_hd__decap_3
XFILLER_85_308 VGND VGND VPWR VPWR sky130_fd_sc_hd__decap_3
XFILLER_98_669 VGND VGND VPWR VPWR sky130_fd_sc_hd__decap_3
X_5010_ _5010_/A _5662_/A _5010_/C _5010_/D VGND VGND VPWR VPWR _5010_/X sky130_fd_sc_hd__or4_2
XFILLER_39_703 VGND VGND VPWR VPWR sky130_fd_sc_hd__decap_3
XFILLER_66_511 VGND VGND VPWR VPWR sky130_fd_sc_hd__decap_3
Xhold1009 _6696_/Q VGND VGND VPWR VPWR _5693_/A1 sky130_fd_sc_hd__dlygate4sd3_1
XFILLER_38_235 VGND VGND VPWR VPWR sky130_fd_sc_hd__decap_3
XFILLER_78_393 VGND VGND VPWR VPWR sky130_fd_sc_hd__decap_3
XFILLER_93_330 VGND VGND VPWR VPWR sky130_fd_sc_hd__decap_3
XFILLER_93_363 VGND VGND VPWR VPWR sky130_fd_sc_hd__fill_1
XFILLER_19_482 VGND VGND VPWR VPWR sky130_fd_sc_hd__decap_3
XFILLER_81_525 VGND VGND VPWR VPWR sky130_fd_sc_hd__decap_3
XFILLER_93_396 VGND VGND VPWR VPWR sky130_fd_sc_hd__decap_3
X_6961_ clkload5/A _6961_/D VGND VGND VPWR VPWR _6961_/Q sky130_fd_sc_hd__dfxtp_2
XFILLER_34_441 VGND VGND VPWR VPWR sky130_fd_sc_hd__decap_3
XFILLER_53_249 VGND VGND VPWR VPWR sky130_fd_sc_hd__decap_3
X_6892_ _6941_/CLK _6892_/D VGND VGND VPWR VPWR _6892_/Q sky130_fd_sc_hd__dfxtp_2
XTAP_TAPCELL_ROW_52_907 VGND VPWR sky130_fd_sc_hd__tapvpwrvgnd_1
XFILLER_22_625 VGND VGND VPWR VPWR sky130_fd_sc_hd__decap_3
XTAP_TAPCELL_ROW_105_1567 VGND VPWR sky130_fd_sc_hd__tapvpwrvgnd_1
XFILLER_21_113 VGND VGND VPWR VPWR sky130_fd_sc_hd__decap_3
XFILLER_22_669 VGND VGND VPWR VPWR sky130_fd_sc_hd__decap_3
XTAP_TAPCELL_ROW_32_664 VGND VPWR sky130_fd_sc_hd__tapvpwrvgnd_1
XTAP_TAPCELL_ROW_32_653 VGND VPWR sky130_fd_sc_hd__tapvpwrvgnd_1
X_4725_ _4969_/B _4720_/X _4723_/X _4724_/X VGND VGND VPWR VPWR _5655_/A sky130_fd_sc_hd__a211o_2
XFILLER_107_207 VGND VGND VPWR VPWR sky130_fd_sc_hd__decap_3
X_7375_ _7388_/CLK _7375_/D _6655_/Y VGND VGND VPWR VPWR _7375_/Q sky130_fd_sc_hd__dfrtp_2
Xhold810 _6797_/Q VGND VGND VPWR VPWR _6797_/D sky130_fd_sc_hd__dlygate4sd3_1
Xhold821 _6854_/Q VGND VGND VPWR VPWR _6854_/D sky130_fd_sc_hd__dlygate4sd3_1
X_4587_ _4587_/A _4593_/B VGND VGND VPWR VPWR _7287_/D sky130_fd_sc_hd__and2_2
X_3607_ _4295_/B _3607_/B VGND VGND VPWR VPWR _3610_/A sky130_fd_sc_hd__nand2_2
XFILLER_89_614 VGND VGND VPWR VPWR sky130_fd_sc_hd__fill_2
Xhold832 _6858_/Q VGND VGND VPWR VPWR _6858_/D sky130_fd_sc_hd__dlygate4sd3_1
Xhold843 _6761_/Q VGND VGND VPWR VPWR _6761_/D sky130_fd_sc_hd__dlygate4sd3_1
Xhold854 _6747_/Q VGND VGND VPWR VPWR _6747_/D sky130_fd_sc_hd__dlygate4sd3_1
X_6326_ _6677_/A VGND VGND VPWR VPWR _6326_/Y sky130_fd_sc_hd__inv_2
X_3538_ _4327_/A _3456_/X _3538_/B1 _3421_/C VGND VGND VPWR VPWR _3544_/B sky130_fd_sc_hd__o2bb2a_2
XFILLER_107_24 VGND VGND VPWR VPWR sky130_fd_sc_hd__decap_3
XFILLER_107_35 VGND VGND VPWR VPWR sky130_fd_sc_hd__decap_3
XFILLER_107_57 VGND VGND VPWR VPWR sky130_fd_sc_hd__decap_3
XFILLER_1_529 VGND VGND VPWR VPWR sky130_fd_sc_hd__decap_3
XFILLER_89_647 VGND VGND VPWR VPWR sky130_fd_sc_hd__decap_3
Xhold865 _6752_/Q VGND VGND VPWR VPWR _6752_/D sky130_fd_sc_hd__dlygate4sd3_1
Xhold876 _6977_/Q VGND VGND VPWR VPWR _6977_/D sky130_fd_sc_hd__dlygate4sd3_1
Xhold887 _6814_/Q VGND VGND VPWR VPWR _6814_/D sky130_fd_sc_hd__dlygate4sd3_1
Xhold898 _6939_/Q VGND VGND VPWR VPWR _6939_/D sky130_fd_sc_hd__dlygate4sd3_1
XFILLER_103_435 VGND VGND VPWR VPWR sky130_fd_sc_hd__decap_3
XFILLER_88_135 VGND VGND VPWR VPWR sky130_fd_sc_hd__decap_3
X_3469_ _3469_/A _3469_/B VGND VGND VPWR VPWR _4537_/C sky130_fd_sc_hd__nor2_1
XFILLER_29_202 VGND VGND VPWR VPWR sky130_fd_sc_hd__decap_3
XFILLER_57_511 VGND VGND VPWR VPWR sky130_fd_sc_hd__decap_3
XFILLER_88_168 VGND VGND VPWR VPWR sky130_fd_sc_hd__decap_3
XTAP_TAPCELL_ROW_4_312 VGND VPWR sky130_fd_sc_hd__tapvpwrvgnd_1
XFILLER_69_382 VGND VGND VPWR VPWR sky130_fd_sc_hd__fill_1
XFILLER_97_691 VGND VGND VPWR VPWR sky130_fd_sc_hd__decap_3
X_5139_ _4677_/B _5138_/X _5092_/C VGND VGND VPWR VPWR _5139_/X sky130_fd_sc_hd__o21a_2
XFILLER_29_246 VGND VGND VPWR VPWR sky130_fd_sc_hd__decap_3
XFILLER_29_279 VGND VGND VPWR VPWR sky130_fd_sc_hd__fill_1
XFILLER_45_706 VGND VGND VPWR VPWR sky130_fd_sc_hd__decap_3
XFILLER_84_341 VGND VGND VPWR VPWR sky130_fd_sc_hd__decap_3
XFILLER_84_363 VGND VGND VPWR VPWR sky130_fd_sc_hd__fill_1
XFILLER_44_227 VGND VGND VPWR VPWR sky130_fd_sc_hd__fill_2
XFILLER_57_599 VGND VGND VPWR VPWR sky130_fd_sc_hd__fill_1
XFILLER_72_536 VGND VGND VPWR VPWR sky130_fd_sc_hd__decap_3
XFILLER_84_374 VGND VGND VPWR VPWR sky130_fd_sc_hd__decap_3
XFILLER_84_396 VGND VGND VPWR VPWR sky130_fd_sc_hd__decap_3
XFILLER_16_21 VGND VGND VPWR VPWR sky130_fd_sc_hd__decap_3
XFILLER_25_430 VGND VGND VPWR VPWR sky130_fd_sc_hd__fill_2
XFILLER_44_249 VGND VGND VPWR VPWR sky130_fd_sc_hd__decap_3
XFILLER_13_603 VGND VGND VPWR VPWR sky130_fd_sc_hd__decap_3
XFILLER_80_580 VGND VGND VPWR VPWR sky130_fd_sc_hd__decap_3
XFILLER_13_647 VGND VGND VPWR VPWR sky130_fd_sc_hd__decap_3
XFILLER_52_282 VGND VGND VPWR VPWR sky130_fd_sc_hd__decap_3
XFILLER_12_157 VGND VGND VPWR VPWR sky130_fd_sc_hd__decap_3
XFILLER_40_477 VGND VGND VPWR VPWR sky130_fd_sc_hd__decap_3
XFILLER_9_629 VGND VGND VPWR VPWR sky130_fd_sc_hd__decap_3
XFILLER_21_691 VGND VGND VPWR VPWR sky130_fd_sc_hd__decap_3
XFILLER_8_128 VGND VGND VPWR VPWR sky130_fd_sc_hd__decap_3
XFILLER_4_312 VGND VGND VPWR VPWR sky130_fd_sc_hd__decap_3
XFILLER_106_262 VGND VGND VPWR VPWR sky130_fd_sc_hd__decap_3
XFILLER_79_102 VGND VGND VPWR VPWR sky130_fd_sc_hd__fill_1
XFILLER_79_113 VGND VGND VPWR VPWR sky130_fd_sc_hd__decap_3
XFILLER_106_295 VGND VGND VPWR VPWR sky130_fd_sc_hd__decap_3
XFILLER_79_146 VGND VGND VPWR VPWR sky130_fd_sc_hd__decap_3
XFILLER_0_573 VGND VGND VPWR VPWR sky130_fd_sc_hd__decap_3
XFILLER_95_617 VGND VGND VPWR VPWR sky130_fd_sc_hd__decap_3
XFILLER_48_533 VGND VGND VPWR VPWR sky130_fd_sc_hd__decap_3
XFILLER_87_190 VGND VGND VPWR VPWR sky130_fd_sc_hd__decap_3
XFILLER_48_555 VGND VGND VPWR VPWR sky130_fd_sc_hd__decap_3
XFILLER_57_72 VGND VGND VPWR VPWR sky130_fd_sc_hd__decap_3
XFILLER_57_83 VGND VGND VPWR VPWR sky130_fd_sc_hd__decap_3
XFILLER_35_205 VGND VGND VPWR VPWR sky130_fd_sc_hd__decap_3
XFILLER_75_396 VGND VGND VPWR VPWR sky130_fd_sc_hd__decap_3
Xplace503 _3561_/B VGND VGND VPWR VPWR _5670_/A sky130_fd_sc_hd__buf_2
XFILLER_16_430 VGND VGND VPWR VPWR sky130_fd_sc_hd__fill_1
XFILLER_35_249 VGND VGND VPWR VPWR sky130_fd_sc_hd__decap_3
XFILLER_51_709 VGND VGND VPWR VPWR sky130_fd_sc_hd__decap_3
XFILLER_90_333 VGND VGND VPWR VPWR sky130_fd_sc_hd__decap_3
Xplace514 _6557_/A VGND VGND VPWR VPWR _6652_/A sky130_fd_sc_hd__buf_2
Xplace525 _6617_/A VGND VGND VPWR VPWR _6647_/A sky130_fd_sc_hd__buf_2
Xplace536 _6613_/A VGND VGND VPWR VPWR _6644_/A sky130_fd_sc_hd__buf_2
Xplace547 _6654_/A VGND VGND VPWR VPWR _6613_/A sky130_fd_sc_hd__buf_2
XFILLER_16_463 VGND VGND VPWR VPWR sky130_fd_sc_hd__decap_3
XFILLER_16_474 VGND VGND VPWR VPWR sky130_fd_sc_hd__fill_2
XFILLER_73_60 VGND VGND VPWR VPWR sky130_fd_sc_hd__decap_3
XFILLER_73_71 VGND VGND VPWR VPWR sky130_fd_sc_hd__decap_3
XFILLER_90_377 VGND VGND VPWR VPWR sky130_fd_sc_hd__decap_3
Xplace558 _6632_/A VGND VGND VPWR VPWR _6612_/A sky130_fd_sc_hd__buf_2
Xplace569 _6626_/A VGND VGND VPWR VPWR _6563_/A sky130_fd_sc_hd__buf_2
XFILLER_31_444 VGND VGND VPWR VPWR sky130_fd_sc_hd__decap_3
XFILLER_43_293 VGND VGND VPWR VPWR sky130_fd_sc_hd__decap_3
XFILLER_71_580 VGND VGND VPWR VPWR sky130_fd_sc_hd__decap_3
XFILLER_92_6 VGND VGND VPWR VPWR sky130_fd_sc_hd__fill_1
XFILLER_31_488 VGND VGND VPWR VPWR sky130_fd_sc_hd__decap_3
XFILLER_8_640 VGND VGND VPWR VPWR sky130_fd_sc_hd__decap_3
XFILLER_117_505 VGND VGND VPWR VPWR sky130_fd_sc_hd__decap_3
XFILLER_7_150 VGND VGND VPWR VPWR sky130_fd_sc_hd__decap_3
XFILLER_8_651 VGND VGND VPWR VPWR sky130_fd_sc_hd__decap_3
X_4510_ _4510_/A0 _7292_/Q _4517_/S VGND VGND VPWR VPWR _7324_/D sky130_fd_sc_hd__mux2_2
XFILLER_8_684 VGND VGND VPWR VPWR sky130_fd_sc_hd__decap_3
X_4441_ _4813_/B _4441_/B VGND VGND VPWR VPWR _4827_/A sky130_fd_sc_hd__nand2_2
XFILLER_113_700 VGND VGND VPWR VPWR sky130_fd_sc_hd__decap_3
X_7160_ _7357_/CLK _7160_/D _6440_/Y VGND VGND VPWR VPWR _7160_/Q sky130_fd_sc_hd__dfrtp_2
XPHY_EDGE_ROW_9_Right_9 VGND VGND VPWR VPWR sky130_fd_sc_hd__decap_3
XFILLER_98_400 VGND VGND VPWR VPWR sky130_fd_sc_hd__decap_3
X_4372_ _4372_/A _4627_/A VGND VGND VPWR VPWR _5018_/A sky130_fd_sc_hd__or2_2
XFILLER_98_466 VGND VGND VPWR VPWR sky130_fd_sc_hd__decap_3
X_7091_ _7350_/CLK _7091_/D _6371_/Y VGND VGND VPWR VPWR _7091_/Q sky130_fd_sc_hd__dfrtp_2
X_3323_ _5129_/A _3519_/B _5294_/A _5129_/B VGND VGND VPWR VPWR _3323_/X sky130_fd_sc_hd__a31o_2
XFILLER_100_405 VGND VGND VPWR VPWR sky130_fd_sc_hd__decap_3
XFILLER_39_511 VGND VGND VPWR VPWR sky130_fd_sc_hd__decap_3
XFILLER_85_105 VGND VGND VPWR VPWR sky130_fd_sc_hd__decap_3
XFILLER_85_116 VGND VGND VPWR VPWR sky130_fd_sc_hd__decap_3
XFILLER_98_477 VGND VGND VPWR VPWR sky130_fd_sc_hd__decap_3
XFILLER_98_499 VGND VGND VPWR VPWR sky130_fd_sc_hd__decap_3
XPHY_EDGE_ROW_107_Right_107 VGND VGND VPWR VPWR sky130_fd_sc_hd__decap_3
XFILLER_100_427 VGND VGND VPWR VPWR sky130_fd_sc_hd__fill_1
XFILLER_100_449 VGND VGND VPWR VPWR sky130_fd_sc_hd__decap_3
XFILLER_79_691 VGND VGND VPWR VPWR sky130_fd_sc_hd__decap_3
XFILLER_85_149 VGND VGND VPWR VPWR sky130_fd_sc_hd__decap_3
XFILLER_27_706 VGND VGND VPWR VPWR sky130_fd_sc_hd__decap_3
XFILLER_78_190 VGND VGND VPWR VPWR sky130_fd_sc_hd__decap_3
XFILLER_94_672 VGND VGND VPWR VPWR sky130_fd_sc_hd__decap_3
XFILLER_26_227 VGND VGND VPWR VPWR sky130_fd_sc_hd__decap_3
XTAP_TAPCELL_ROW_37_723 VGND VPWR sky130_fd_sc_hd__tapvpwrvgnd_1
XFILLER_19_290 VGND VGND VPWR VPWR sky130_fd_sc_hd__decap_3
XFILLER_81_355 VGND VGND VPWR VPWR sky130_fd_sc_hd__fill_2
XFILLER_93_193 VGND VGND VPWR VPWR sky130_fd_sc_hd__decap_3
X_6944_ _6944_/CLK _6944_/D VGND VGND VPWR VPWR _6944_/Q sky130_fd_sc_hd__dfxtp_2
XFILLER_81_377 VGND VGND VPWR VPWR sky130_fd_sc_hd__decap_3
XFILLER_22_411 VGND VGND VPWR VPWR sky130_fd_sc_hd__decap_3
XFILLER_22_433 VGND VGND VPWR VPWR sky130_fd_sc_hd__decap_3
X_6875_ _6923_/CLK _6875_/D VGND VGND VPWR VPWR _6875_/Q sky130_fd_sc_hd__dfxtp_2
XTAP_TAPCELL_ROW_66_1083 VGND VPWR sky130_fd_sc_hd__tapvpwrvgnd_1
XFILLER_22_477 VGND VGND VPWR VPWR sky130_fd_sc_hd__decap_3
XFILLER_10_628 VGND VGND VPWR VPWR sky130_fd_sc_hd__decap_3
XFILLER_108_505 VGND VGND VPWR VPWR sky130_fd_sc_hd__decap_3
X_4708_ _7001_/Q _4825_/B VGND VGND VPWR VPWR _4826_/A sky130_fd_sc_hd__and2_2
XTAP_TAPCELL_ROW_118_1736 VGND VPWR sky130_fd_sc_hd__tapvpwrvgnd_1
X_5688_ _7350_/Q _5688_/A1 _5708_/S VGND VGND VPWR VPWR _5688_/X sky130_fd_sc_hd__mux2_2
XFILLER_118_56 VGND VGND VPWR VPWR sky130_fd_sc_hd__decap_3
X_4639_ _4639_/A _4948_/B VGND VGND VPWR VPWR _4918_/A sky130_fd_sc_hd__or2_2
XFILLER_116_582 VGND VGND VPWR VPWR sky130_fd_sc_hd__decap_3
XFILLER_1_304 VGND VGND VPWR VPWR sky130_fd_sc_hd__decap_3
X_7358_ _7358_/CLK _7358_/D _6638_/Y VGND VGND VPWR VPWR _7358_/Q sky130_fd_sc_hd__dfrtp_2
XFILLER_103_243 VGND VGND VPWR VPWR sky130_fd_sc_hd__decap_3
XFILLER_1_348 VGND VGND VPWR VPWR sky130_fd_sc_hd__fill_2
XFILLER_89_433 VGND VGND VPWR VPWR sky130_fd_sc_hd__decap_3
XFILLER_89_455 VGND VGND VPWR VPWR sky130_fd_sc_hd__decap_3
X_7289_ _7322_/CLK _7289_/D _6569_/Y VGND VGND VPWR VPWR _7289_/Q sky130_fd_sc_hd__dfrtp_2
Xhold684 _6912_/Q VGND VGND VPWR VPWR _6912_/D sky130_fd_sc_hd__dlygate4sd3_1
Xhold695 _6897_/Q VGND VGND VPWR VPWR _6897_/D sky130_fd_sc_hd__dlygate4sd3_1
X_6309_ _6535_/A VGND VGND VPWR VPWR _6309_/Y sky130_fd_sc_hd__inv_2
XFILLER_77_617 VGND VGND VPWR VPWR sky130_fd_sc_hd__decap_3
XFILLER_85_650 VGND VGND VPWR VPWR sky130_fd_sc_hd__decap_3
XFILLER_84_182 VGND VGND VPWR VPWR sky130_fd_sc_hd__decap_3
XFILLER_85_694 VGND VGND VPWR VPWR sky130_fd_sc_hd__decap_3
XFILLER_33_709 VGND VGND VPWR VPWR sky130_fd_sc_hd__decap_3
XFILLER_72_388 VGND VGND VPWR VPWR sky130_fd_sc_hd__decap_3
XFILLER_13_422 VGND VGND VPWR VPWR sky130_fd_sc_hd__fill_1
XFILLER_25_271 VGND VGND VPWR VPWR sky130_fd_sc_hd__decap_3
XFILLER_25_293 VGND VGND VPWR VPWR sky130_fd_sc_hd__decap_3
XFILLER_40_230 VGND VGND VPWR VPWR sky130_fd_sc_hd__decap_3
XFILLER_40_274 VGND VGND VPWR VPWR sky130_fd_sc_hd__decap_3
XFILLER_43_85 VGND VGND VPWR VPWR sky130_fd_sc_hd__decap_3
XFILLER_5_632 VGND VGND VPWR VPWR sky130_fd_sc_hd__decap_3
XFILLER_4_120 VGND VGND VPWR VPWR sky130_fd_sc_hd__decap_3
XFILLER_5_665 VGND VGND VPWR VPWR sky130_fd_sc_hd__decap_3
XTAP_TAPCELL_ROW_93_1419 VGND VPWR sky130_fd_sc_hd__tapvpwrvgnd_1
XFILLER_4_175 VGND VGND VPWR VPWR sky130_fd_sc_hd__decap_3
XFILLER_5_676 VGND VGND VPWR VPWR sky130_fd_sc_hd__decap_3
XFILLER_68_606 VGND VGND VPWR VPWR sky130_fd_sc_hd__decap_3
XFILLER_68_639 VGND VGND VPWR VPWR sky130_fd_sc_hd__decap_3
XFILLER_95_414 VGND VGND VPWR VPWR sky130_fd_sc_hd__decap_3
XFILLER_67_127 VGND VGND VPWR VPWR sky130_fd_sc_hd__fill_1
XFILLER_76_672 VGND VGND VPWR VPWR sky130_fd_sc_hd__decap_3
XFILLER_91_620 VGND VGND VPWR VPWR sky130_fd_sc_hd__decap_3
XFILLER_75_193 VGND VGND VPWR VPWR sky130_fd_sc_hd__decap_3
XFILLER_84_81 VGND VGND VPWR VPWR sky130_fd_sc_hd__decap_3
XFILLER_90_141 VGND VGND VPWR VPWR sky130_fd_sc_hd__decap_3
XFILLER_91_653 VGND VGND VPWR VPWR sky130_fd_sc_hd__decap_3
Xplace322 _3925_/B1 VGND VGND VPWR VPWR _3922_/B1 sky130_fd_sc_hd__buf_2
XFILLER_90_163 VGND VGND VPWR VPWR sky130_fd_sc_hd__decap_3
XFILLER_91_697 VGND VGND VPWR VPWR sky130_fd_sc_hd__decap_3
Xplace355 _3665_/B VGND VGND VPWR VPWR _3661_/B sky130_fd_sc_hd__buf_2
Xplace344 _3887_/A2 VGND VGND VPWR VPWR _3889_/B1 sky130_fd_sc_hd__buf_2
Xplace333 _3921_/A2 VGND VGND VPWR VPWR _3926_/A2 sky130_fd_sc_hd__buf_2
X_4990_ _4620_/A _4989_/X _4374_/X VGND VGND VPWR VPWR _5004_/B sky130_fd_sc_hd__o21ai_2
XFILLER_16_271 VGND VGND VPWR VPWR sky130_fd_sc_hd__decap_3
XFILLER_51_539 VGND VGND VPWR VPWR sky130_fd_sc_hd__fill_2
Xplace388 _3407_/X VGND VGND VPWR VPWR _4333_/A2 sky130_fd_sc_hd__buf_2
Xplace377 _4601_/S VGND VGND VPWR VPWR _4356_/A2 sky130_fd_sc_hd__buf_2
Xplace366 _5020_/A VGND VGND VPWR VPWR _4814_/A sky130_fd_sc_hd__buf_2
X_3941_ _7369_/Q _4484_/A0 _3945_/S VGND VGND VPWR VPWR _7369_/D sky130_fd_sc_hd__mux2_2
XTAP_TAPCELL_ROW_102_1537 VGND VPWR sky130_fd_sc_hd__tapvpwrvgnd_1
Xplace399 _5072_/A VGND VGND VPWR VPWR _5114_/A sky130_fd_sc_hd__buf_2
X_6660_ _6662_/A VGND VGND VPWR VPWR _6660_/Y sky130_fd_sc_hd__inv_2
X_3872_ _6921_/Q _3906_/A2 _5660_/B _6695_/Q _3871_/X VGND VGND VPWR VPWR _3872_/X
+ sky130_fd_sc_hd__a221o_2
X_6591_ _6625_/A VGND VGND VPWR VPWR _6591_/Y sky130_fd_sc_hd__inv_2
X_5611_ _5611_/A _5634_/B VGND VGND VPWR VPWR _7022_/D sky130_fd_sc_hd__and2_2
XTAP_TAPCELL_ROW_42_781 VGND VPWR sky130_fd_sc_hd__tapvpwrvgnd_1
XFILLER_117_313 VGND VGND VPWR VPWR sky130_fd_sc_hd__fill_2
XFILLER_105_508 VGND VGND VPWR VPWR sky130_fd_sc_hd__fill_2
X_7212_ _7372_/CLK _7212_/D _6492_/Y VGND VGND VPWR VPWR _7212_/Q sky130_fd_sc_hd__dfrtp_2
X_4424_ _4425_/A _4425_/C _4649_/B VGND VGND VPWR VPWR _4446_/A sky130_fd_sc_hd__a21oi_2
X_7143_ _7406_/CLK _7143_/D _6423_/Y VGND VGND VPWR VPWR _7143_/Q sky130_fd_sc_hd__dfrtp_2
X_4355_ _4355_/A _4355_/B VGND VGND VPWR VPWR _4355_/X sky130_fd_sc_hd__or2_2
XTAP_TAPCELL_ROW_113_1666 VGND VPWR sky130_fd_sc_hd__tapvpwrvgnd_1
XFILLER_101_703 VGND VGND VPWR VPWR sky130_fd_sc_hd__decap_3
XFILLER_59_617 VGND VGND VPWR VPWR sky130_fd_sc_hd__decap_3
XFILLER_86_414 VGND VGND VPWR VPWR sky130_fd_sc_hd__decap_3
X_7074_ _7403_/CLK _7074_/D _6354_/Y VGND VGND VPWR VPWR _7074_/Q sky130_fd_sc_hd__dfrtp_2
X_3306_ _3340_/A _3328_/A _6981_/D _4696_/B _3340_/B VGND VGND VPWR VPWR _3378_/A
+ sky130_fd_sc_hd__o221a_2
XFILLER_100_235 VGND VGND VPWR VPWR sky130_fd_sc_hd__decap_3
XFILLER_113_585 VGND VGND VPWR VPWR sky130_fd_sc_hd__decap_3
XFILLER_58_116 VGND VGND VPWR VPWR sky130_fd_sc_hd__decap_3
XFILLER_86_436 VGND VGND VPWR VPWR sky130_fd_sc_hd__decap_3
X_4286_ _4286_/A _4286_/B VGND VGND VPWR VPWR _4288_/C sky130_fd_sc_hd__or2_2
XFILLER_100_268 VGND VGND VPWR VPWR sky130_fd_sc_hd__decap_3
XFILLER_104_25 VGND VGND VPWR VPWR sky130_fd_sc_hd__decap_3
XFILLER_67_650 VGND VGND VPWR VPWR sky130_fd_sc_hd__decap_3
XFILLER_74_609 VGND VGND VPWR VPWR sky130_fd_sc_hd__decap_3
XFILLER_86_469 VGND VGND VPWR VPWR sky130_fd_sc_hd__decap_3
XFILLER_104_69 VGND VGND VPWR VPWR sky130_fd_sc_hd__decap_3
XFILLER_27_503 VGND VGND VPWR VPWR sky130_fd_sc_hd__fill_1
XFILLER_39_363 VGND VGND VPWR VPWR sky130_fd_sc_hd__fill_2
XFILLER_39_385 VGND VGND VPWR VPWR sky130_fd_sc_hd__decap_3
XFILLER_67_694 VGND VGND VPWR VPWR sky130_fd_sc_hd__decap_3
XFILLER_73_119 VGND VGND VPWR VPWR sky130_fd_sc_hd__decap_3
XTAP_TAPCELL_ROW_68_1112 VGND VPWR sky130_fd_sc_hd__tapvpwrvgnd_1
XFILLER_15_709 VGND VGND VPWR VPWR sky130_fd_sc_hd__decap_3
XFILLER_27_558 VGND VGND VPWR VPWR sky130_fd_sc_hd__fill_2
XFILLER_39_396 VGND VGND VPWR VPWR sky130_fd_sc_hd__decap_3
XFILLER_82_631 VGND VGND VPWR VPWR sky130_fd_sc_hd__decap_3
XFILLER_81_152 VGND VGND VPWR VPWR sky130_fd_sc_hd__decap_3
XFILLER_82_675 VGND VGND VPWR VPWR sky130_fd_sc_hd__decap_3
XFILLER_35_591 VGND VGND VPWR VPWR sky130_fd_sc_hd__decap_3
XFILLER_54_399 VGND VGND VPWR VPWR sky130_fd_sc_hd__decap_3
X_6927_ _6942_/CLK _6927_/D VGND VGND VPWR VPWR _6927_/Q sky130_fd_sc_hd__dfxtp_2
X_6858_ _6906_/CLK _6858_/D VGND VGND VPWR VPWR _6858_/Q sky130_fd_sc_hd__dfxtp_2
XTAP_TAPCELL_ROW_12_409 VGND VPWR sky130_fd_sc_hd__tapvpwrvgnd_1
XFILLER_22_274 VGND VGND VPWR VPWR sky130_fd_sc_hd__decap_3
X_6789_ clkload4/A _6789_/D VGND VGND VPWR VPWR _6789_/Q sky130_fd_sc_hd__dfxtp_2
XFILLER_6_429 VGND VGND VPWR VPWR sky130_fd_sc_hd__decap_3
XTAP_TAPCELL_ROW_79_1241 VGND VPWR sky130_fd_sc_hd__tapvpwrvgnd_1
XFILLER_108_346 VGND VGND VPWR VPWR sky130_fd_sc_hd__decap_3
XFILLER_2_613 VGND VGND VPWR VPWR sky130_fd_sc_hd__decap_3
XFILLER_2_657 VGND VGND VPWR VPWR sky130_fd_sc_hd__decap_3
XFILLER_104_563 VGND VGND VPWR VPWR sky130_fd_sc_hd__fill_1
XFILLER_1_167 VGND VGND VPWR VPWR sky130_fd_sc_hd__fill_1
XFILLER_77_414 VGND VGND VPWR VPWR sky130_fd_sc_hd__decap_3
XFILLER_89_274 VGND VGND VPWR VPWR sky130_fd_sc_hd__decap_3
XFILLER_38_41 VGND VGND VPWR VPWR sky130_fd_sc_hd__decap_3
XFILLER_38_63 VGND VGND VPWR VPWR sky130_fd_sc_hd__decap_3
XFILLER_65_609 VGND VGND VPWR VPWR sky130_fd_sc_hd__decap_3
XFILLER_77_458 VGND VGND VPWR VPWR sky130_fd_sc_hd__decap_3
XFILLER_92_406 VGND VGND VPWR VPWR sky130_fd_sc_hd__fill_2
XFILLER_18_503 VGND VGND VPWR VPWR sky130_fd_sc_hd__fill_1
XFILLER_57_160 VGND VGND VPWR VPWR sky130_fd_sc_hd__decap_3
XFILLER_58_672 VGND VGND VPWR VPWR sky130_fd_sc_hd__decap_3
XFILLER_73_620 VGND VGND VPWR VPWR sky130_fd_sc_hd__decap_3
Xhold1170 _7039_/Q VGND VGND VPWR VPWR _5579_/A0 sky130_fd_sc_hd__dlygate4sd3_1
XFILLER_45_322 VGND VGND VPWR VPWR sky130_fd_sc_hd__decap_3
XFILLER_57_182 VGND VGND VPWR VPWR sky130_fd_sc_hd__decap_3
XFILLER_73_653 VGND VGND VPWR VPWR sky130_fd_sc_hd__decap_3
Xhold1181 _7306_/Q VGND VGND VPWR VPWR _4548_/A sky130_fd_sc_hd__dlygate4sd3_1
Xhold1192 _7130_/Q VGND VGND VPWR VPWR _5407_/A0 sky130_fd_sc_hd__dlygate4sd3_1
XFILLER_45_355 VGND VGND VPWR VPWR sky130_fd_sc_hd__decap_3
XFILLER_60_303 VGND VGND VPWR VPWR sky130_fd_sc_hd__fill_2
XFILLER_72_141 VGND VGND VPWR VPWR sky130_fd_sc_hd__decap_3
XFILLER_73_697 VGND VGND VPWR VPWR sky130_fd_sc_hd__decap_3
XFILLER_33_539 VGND VGND VPWR VPWR sky130_fd_sc_hd__decap_3
XFILLER_60_347 VGND VGND VPWR VPWR sky130_fd_sc_hd__fill_2
XFILLER_72_174 VGND VGND VPWR VPWR sky130_fd_sc_hd__decap_3
XFILLER_13_252 VGND VGND VPWR VPWR sky130_fd_sc_hd__decap_3
XFILLER_41_550 VGND VGND VPWR VPWR sky130_fd_sc_hd__decap_3
XFILLER_41_594 VGND VGND VPWR VPWR sky130_fd_sc_hd__decap_3
XFILLER_9_267 VGND VGND VPWR VPWR sky130_fd_sc_hd__decap_3
XFILLER_70_72 VGND VGND VPWR VPWR sky130_fd_sc_hd__decap_3
XFILLER_70_94 VGND VGND VPWR VPWR sky130_fd_sc_hd__decap_3
Xclkload15 _7349_/CLK VGND VGND VPWR VPWR clkload15/Y sky130_fd_sc_hd__bufinv_16
Xclkload26 _7086_/CLK VGND VGND VPWR VPWR clkload26/Y sky130_fd_sc_hd__inv_6
Xclkload37 _7373_/CLK VGND VGND VPWR VPWR clkload37/Y sky130_fd_sc_hd__clkinv_2
XFILLER_5_473 VGND VGND VPWR VPWR sky130_fd_sc_hd__decap_3
XFILLER_79_81 VGND VGND VPWR VPWR sky130_fd_sc_hd__decap_3
XFILLER_96_701 VGND VGND VPWR VPWR sky130_fd_sc_hd__decap_3
X_4140_ _4117_/Y _4124_/B _4890_/B _4886_/A VGND VGND VPWR VPWR _4140_/X sky130_fd_sc_hd__a2bb2o_2
XFILLER_110_533 VGND VGND VPWR VPWR sky130_fd_sc_hd__decap_3
XFILLER_68_436 VGND VGND VPWR VPWR sky130_fd_sc_hd__decap_3
XFILLER_95_200 VGND VGND VPWR VPWR sky130_fd_sc_hd__decap_3
XFILLER_49_650 VGND VGND VPWR VPWR sky130_fd_sc_hd__decap_3
XFILLER_68_458 VGND VGND VPWR VPWR sky130_fd_sc_hd__fill_1
XFILLER_95_244 VGND VGND VPWR VPWR sky130_fd_sc_hd__fill_2
X_4071_ _7307_/Q _4488_/S _4181_/B1 _7371_/Q _4429_/C1 VGND VGND VPWR VPWR _4071_/X
+ sky130_fd_sc_hd__a221o_2
XFILLER_48_160 VGND VGND VPWR VPWR sky130_fd_sc_hd__decap_3
XFILLER_49_694 VGND VGND VPWR VPWR sky130_fd_sc_hd__decap_3
XFILLER_76_480 VGND VGND VPWR VPWR sky130_fd_sc_hd__decap_3
XFILLER_48_193 VGND VGND VPWR VPWR sky130_fd_sc_hd__decap_3
XFILLER_64_631 VGND VGND VPWR VPWR sky130_fd_sc_hd__decap_3
XTAP_TAPCELL_ROW_47_840 VGND VPWR sky130_fd_sc_hd__tapvpwrvgnd_1
XFILLER_36_355 VGND VGND VPWR VPWR sky130_fd_sc_hd__decap_3
XFILLER_64_675 VGND VGND VPWR VPWR sky130_fd_sc_hd__decap_3
XTAP_TAPCELL_ROW_47_851 VGND VPWR sky130_fd_sc_hd__tapvpwrvgnd_1
XFILLER_24_539 VGND VGND VPWR VPWR sky130_fd_sc_hd__decap_3
XFILLER_91_483 VGND VGND VPWR VPWR sky130_fd_sc_hd__decap_3
X_4973_ _5579_/S _4973_/B _3813_/Y VGND VGND VPWR VPWR _4973_/X sky130_fd_sc_hd__or3b_2
XFILLER_51_369 VGND VGND VPWR VPWR sky130_fd_sc_hd__decap_3
X_6712_ _6941_/CLK _6712_/D VGND VGND VPWR VPWR _6712_/Q sky130_fd_sc_hd__dfxtp_2
X_3924_ _3924_/A1 _5151_/A _3923_/X VGND VGND VPWR VPWR _7376_/D sky130_fd_sc_hd__o21a_2
XTAP_TAPCELL_ROW_63_1042 VGND VPWR sky130_fd_sc_hd__tapvpwrvgnd_1
XFILLER_20_701 VGND VGND VPWR VPWR sky130_fd_sc_hd__decap_3
X_6643_ _6654_/A VGND VGND VPWR VPWR _6643_/Y sky130_fd_sc_hd__inv_2
Xclkload9 clkload9/A VGND VGND VPWR VPWR clkload9/Y sky130_fd_sc_hd__clkinv_2
X_3855_ _3728_/Y _3847_/X _3849_/X _3714_/X _3854_/X VGND VGND VPWR VPWR _3855_/X
+ sky130_fd_sc_hd__a221o_2
XFILLER_118_622 VGND VGND VPWR VPWR sky130_fd_sc_hd__decap_3
X_6574_ _6608_/A VGND VGND VPWR VPWR _6574_/Y sky130_fd_sc_hd__inv_2
X_3786_ _6751_/Q _3661_/X _3890_/B1 _6733_/Q VGND VGND VPWR VPWR _3786_/X sky130_fd_sc_hd__a22o_2
XFILLER_118_666 VGND VGND VPWR VPWR sky130_fd_sc_hd__decap_3
XFILLER_105_316 VGND VGND VPWR VPWR sky130_fd_sc_hd__decap_3
XFILLER_118_699 VGND VGND VPWR VPWR sky130_fd_sc_hd__fill_1
XFILLER_105_349 VGND VGND VPWR VPWR sky130_fd_sc_hd__decap_3
X_4407_ _7370_/Q _4394_/B _4436_/B1 _7178_/Q _4406_/X VGND VGND VPWR VPWR _4407_/X
+ sky130_fd_sc_hd__a221o_2
XFILLER_87_712 VGND VGND VPWR VPWR sky130_fd_sc_hd__fill_2
Xoutput586 _5663_/C VGND VGND VPWR VPWR alu_result_out[22] sky130_fd_sc_hd__clkdlybuf4s25_1
Xoutput575 _5658_/B VGND VGND VPWR VPWR alu_result_out[12] sky130_fd_sc_hd__clkdlybuf4s25_1
XTAP_TAPCELL_ROW_74_1182 VGND VPWR sky130_fd_sc_hd__tapvpwrvgnd_1
XFILLER_101_500 VGND VGND VPWR VPWR sky130_fd_sc_hd__decap_3
XFILLER_101_533 VGND VGND VPWR VPWR sky130_fd_sc_hd__decap_3
XFILLER_113_393 VGND VGND VPWR VPWR sky130_fd_sc_hd__decap_3
XFILLER_115_24 VGND VGND VPWR VPWR sky130_fd_sc_hd__decap_3
XFILLER_59_414 VGND VGND VPWR VPWR sky130_fd_sc_hd__decap_3
XFILLER_59_436 VGND VGND VPWR VPWR sky130_fd_sc_hd__fill_1
X_7126_ _7345_/CLK _7126_/D _6406_/Y VGND VGND VPWR VPWR _7126_/Q sky130_fd_sc_hd__dfrtp_2
Xoutput597 place111/X VGND VGND VPWR VPWR alu_result_out[3] sky130_fd_sc_hd__clkdlybuf4s25_1
X_4338_ _7319_/Q _3996_/S _4338_/B1 _7351_/Q _4347_/C1 VGND VGND VPWR VPWR _4338_/X
+ sky130_fd_sc_hd__a221o_2
XFILLER_115_57 VGND VGND VPWR VPWR sky130_fd_sc_hd__decap_3
XFILLER_59_458 VGND VGND VPWR VPWR sky130_fd_sc_hd__decap_3
XFILLER_75_28 VGND VGND VPWR VPWR sky130_fd_sc_hd__decap_3
XFILLER_86_233 VGND VGND VPWR VPWR sky130_fd_sc_hd__decap_3
X_7057_ _7349_/CLK _7057_/D _6337_/Y VGND VGND VPWR VPWR _7057_/Q sky130_fd_sc_hd__dfrtp_2
X_4269_ _7230_/Q _4353_/A2 _4269_/B1 _7043_/Q _4268_/X VGND VGND VPWR VPWR _4271_/C
+ sky130_fd_sc_hd__a221o_2
XFILLER_101_577 VGND VGND VPWR VPWR sky130_fd_sc_hd__decap_3
XFILLER_101_599 VGND VGND VPWR VPWR sky130_fd_sc_hd__fill_2
XFILLER_27_300 VGND VGND VPWR VPWR sky130_fd_sc_hd__decap_3
XFILLER_55_620 VGND VGND VPWR VPWR sky130_fd_sc_hd__decap_3
XFILLER_86_288 VGND VGND VPWR VPWR sky130_fd_sc_hd__decap_3
XFILLER_55_653 VGND VGND VPWR VPWR sky130_fd_sc_hd__decap_3
XFILLER_27_355 VGND VGND VPWR VPWR sky130_fd_sc_hd__decap_3
XFILLER_54_141 VGND VGND VPWR VPWR sky130_fd_sc_hd__decap_3
XFILLER_70_601 VGND VGND VPWR VPWR sky130_fd_sc_hd__decap_3
XFILLER_55_697 VGND VGND VPWR VPWR sky130_fd_sc_hd__decap_3
XFILLER_70_634 VGND VGND VPWR VPWR sky130_fd_sc_hd__decap_3
XFILLER_70_645 VGND VGND VPWR VPWR sky130_fd_sc_hd__decap_3
XFILLER_70_678 VGND VGND VPWR VPWR sky130_fd_sc_hd__decap_3
XTAP_TAPCELL_ROW_25_567 VGND VPWR sky130_fd_sc_hd__tapvpwrvgnd_1
XFILLER_10_200 VGND VGND VPWR VPWR sky130_fd_sc_hd__decap_3
XFILLER_11_712 VGND VGND VPWR VPWR sky130_fd_sc_hd__fill_2
XFILLER_24_65 VGND VGND VPWR VPWR sky130_fd_sc_hd__fill_2
XFILLER_23_594 VGND VGND VPWR VPWR sky130_fd_sc_hd__decap_3
XFILLER_109_611 VGND VGND VPWR VPWR sky130_fd_sc_hd__decap_3
XFILLER_6_226 VGND VGND VPWR VPWR sky130_fd_sc_hd__fill_1
XFILLER_109_644 VGND VGND VPWR VPWR sky130_fd_sc_hd__decap_3
XFILLER_6_248 VGND VGND VPWR VPWR sky130_fd_sc_hd__decap_3
XFILLER_109_688 VGND VGND VPWR VPWR sky130_fd_sc_hd__decap_3
XFILLER_108_187 VGND VGND VPWR VPWR sky130_fd_sc_hd__decap_3
XFILLER_2_421 VGND VGND VPWR VPWR sky130_fd_sc_hd__fill_2
XFILLER_111_308 VGND VGND VPWR VPWR sky130_fd_sc_hd__decap_3
XFILLER_2_465 VGND VGND VPWR VPWR sky130_fd_sc_hd__decap_3
XFILLER_78_701 VGND VGND VPWR VPWR sky130_fd_sc_hd__decap_3
XFILLER_104_360 VGND VGND VPWR VPWR sky130_fd_sc_hd__decap_3
XFILLER_104_371 VGND VGND VPWR VPWR sky130_fd_sc_hd__decap_3
XFILLER_2_498 VGND VGND VPWR VPWR sky130_fd_sc_hd__decap_3
XFILLER_37_108 VGND VGND VPWR VPWR sky130_fd_sc_hd__decap_3
XFILLER_92_203 VGND VGND VPWR VPWR sky130_fd_sc_hd__fill_2
XFILLER_46_631 VGND VGND VPWR VPWR sky130_fd_sc_hd__decap_3
XFILLER_58_480 VGND VGND VPWR VPWR sky130_fd_sc_hd__fill_1
XFILLER_58_491 VGND VGND VPWR VPWR sky130_fd_sc_hd__decap_3
XFILLER_18_377 VGND VGND VPWR VPWR sky130_fd_sc_hd__decap_3
XFILLER_46_675 VGND VGND VPWR VPWR sky130_fd_sc_hd__decap_3
XFILLER_33_314 VGND VGND VPWR VPWR sky130_fd_sc_hd__decap_3
XFILLER_60_111 VGND VGND VPWR VPWR sky130_fd_sc_hd__decap_3
XFILLER_60_122 VGND VGND VPWR VPWR sky130_fd_sc_hd__decap_3
XFILLER_61_623 VGND VGND VPWR VPWR sky130_fd_sc_hd__decap_3
XFILLER_73_494 VGND VGND VPWR VPWR sky130_fd_sc_hd__decap_3
XTAP_TAPCELL_ROW_44_810 VGND VPWR sky130_fd_sc_hd__tapvpwrvgnd_1
XFILLER_60_144 VGND VGND VPWR VPWR sky130_fd_sc_hd__decap_3
XFILLER_61_656 VGND VGND VPWR VPWR sky130_fd_sc_hd__decap_3
XFILLER_81_60 VGND VGND VPWR VPWR sky130_fd_sc_hd__decap_3
XFILLER_119_408 VGND VGND VPWR VPWR sky130_fd_sc_hd__decap_3
X_3640_ _3635_/X _3637_/X _3639_/X VGND VGND VPWR VPWR _3665_/B sky130_fd_sc_hd__o21ba_2
X_3571_ _3326_/A _3424_/S _5648_/B _3569_/X _3570_/X VGND VGND VPWR VPWR _3607_/B
+ sky130_fd_sc_hd__o32a_2
XFILLER_115_614 VGND VGND VPWR VPWR sky130_fd_sc_hd__fill_2
XFILLER_53_3 VGND VGND VPWR VPWR sky130_fd_sc_hd__decap_3
X_6290_ _6649_/A VGND VGND VPWR VPWR _6290_/Y sky130_fd_sc_hd__inv_2
X_5310_ _5310_/A0 _4836_/X _5315_/S VGND VGND VPWR VPWR _7175_/D sky130_fd_sc_hd__mux2_2
XFILLER_115_647 VGND VGND VPWR VPWR sky130_fd_sc_hd__decap_3
XFILLER_5_270 VGND VGND VPWR VPWR sky130_fd_sc_hd__decap_3
XFILLER_5_281 VGND VGND VPWR VPWR sky130_fd_sc_hd__decap_3
XFILLER_69_712 VGND VGND VPWR VPWR sky130_fd_sc_hd__fill_2
X_5241_ _5241_/A0 _4806_/X _5272_/S VGND VGND VPWR VPWR _7209_/D sky130_fd_sc_hd__mux2_2
XFILLER_96_531 VGND VGND VPWR VPWR sky130_fd_sc_hd__fill_1
XTAP_TAPCELL_ROW_110_1636 VGND VPWR sky130_fd_sc_hd__tapvpwrvgnd_1
XFILLER_110_330 VGND VGND VPWR VPWR sky130_fd_sc_hd__fill_2
XFILLER_29_609 VGND VGND VPWR VPWR sky130_fd_sc_hd__decap_3
XFILLER_68_244 VGND VGND VPWR VPWR sky130_fd_sc_hd__decap_3
XFILLER_84_704 VGND VGND VPWR VPWR sky130_fd_sc_hd__decap_3
X_4123_ _4119_/X _4122_/X _4327_/A VGND VGND VPWR VPWR _4124_/B sky130_fd_sc_hd__o21a_2
XFILLER_56_439 VGND VGND VPWR VPWR sky130_fd_sc_hd__fill_2
XFILLER_83_214 VGND VGND VPWR VPWR sky130_fd_sc_hd__decap_3
X_4054_ _4054_/A _4456_/A VGND VGND VPWR VPWR _4658_/A sky130_fd_sc_hd__nand2_2
XFILLER_37_620 VGND VGND VPWR VPWR sky130_fd_sc_hd__decap_3
XFILLER_83_225 VGND VGND VPWR VPWR sky130_fd_sc_hd__decap_3
XFILLER_83_247 VGND VGND VPWR VPWR sky130_fd_sc_hd__decap_3
XFILLER_36_141 VGND VGND VPWR VPWR sky130_fd_sc_hd__decap_3
XFILLER_37_653 VGND VGND VPWR VPWR sky130_fd_sc_hd__decap_3
XFILLER_71_409 VGND VGND VPWR VPWR sky130_fd_sc_hd__decap_3
XFILLER_83_269 VGND VGND VPWR VPWR sky130_fd_sc_hd__fill_2
XFILLER_24_303 VGND VGND VPWR VPWR sky130_fd_sc_hd__decap_3
XFILLER_37_697 VGND VGND VPWR VPWR sky130_fd_sc_hd__decap_3
XFILLER_52_634 VGND VGND VPWR VPWR sky130_fd_sc_hd__decap_3
XFILLER_52_645 VGND VGND VPWR VPWR sky130_fd_sc_hd__decap_3
XFILLER_64_483 VGND VGND VPWR VPWR sky130_fd_sc_hd__decap_3
XFILLER_101_37 VGND VGND VPWR VPWR sky130_fd_sc_hd__fill_1
XFILLER_24_347 VGND VGND VPWR VPWR sky130_fd_sc_hd__decap_3
XFILLER_24_358 VGND VGND VPWR VPWR sky130_fd_sc_hd__decap_3
XFILLER_52_678 VGND VGND VPWR VPWR sky130_fd_sc_hd__decap_3
XFILLER_91_291 VGND VGND VPWR VPWR sky130_fd_sc_hd__decap_3
X_4956_ _4948_/Y _4951_/Y _4954_/X _4955_/X VGND VGND VPWR VPWR _5662_/C sky130_fd_sc_hd__a211o_2
X_4887_ _4886_/A _4890_/B _4814_/A VGND VGND VPWR VPWR _4887_/Y sky130_fd_sc_hd__a21oi_2
X_3907_ _6781_/Q _3922_/A2 _3911_/B1 _6869_/Q _3906_/X VGND VGND VPWR VPWR _3907_/X
+ sky130_fd_sc_hd__a221o_2
XTAP_TAPCELL_ROW_22_537 VGND VPWR sky130_fd_sc_hd__tapvpwrvgnd_1
XFILLER_20_553 VGND VGND VPWR VPWR sky130_fd_sc_hd__decap_3
X_6626_ _6626_/A VGND VGND VPWR VPWR _6626_/Y sky130_fd_sc_hd__inv_2
X_3838_ _6773_/Q _3851_/A2 _3853_/A2 _6761_/Q _3837_/X VGND VGND VPWR VPWR _3838_/X
+ sky130_fd_sc_hd__a221o_2
XTAP_TAPCELL_ROW_50_879 VGND VPWR sky130_fd_sc_hd__tapvpwrvgnd_1
XFILLER_20_586 VGND VGND VPWR VPWR sky130_fd_sc_hd__fill_2
X_6557_ _6557_/A VGND VGND VPWR VPWR _6557_/Y sky130_fd_sc_hd__inv_2
XFILLER_106_625 VGND VGND VPWR VPWR sky130_fd_sc_hd__decap_3
XFILLER_118_474 VGND VGND VPWR VPWR sky130_fd_sc_hd__fill_2
X_3769_ _3746_/C _3767_/X _3768_/X _4770_/A1 VGND VGND VPWR VPWR _4944_/B sky130_fd_sc_hd__o31a_2
XTAP_TAPCELL_ROW_76_1211 VGND VPWR sky130_fd_sc_hd__tapvpwrvgnd_1
XFILLER_105_113 VGND VGND VPWR VPWR sky130_fd_sc_hd__decap_3
XFILLER_105_135 VGND VGND VPWR VPWR sky130_fd_sc_hd__decap_3
X_6488_ _6648_/A VGND VGND VPWR VPWR _6488_/Y sky130_fd_sc_hd__inv_2
XFILLER_106_669 VGND VGND VPWR VPWR sky130_fd_sc_hd__decap_3
XFILLER_10_56 VGND VGND VPWR VPWR sky130_fd_sc_hd__fill_2
XFILLER_10_78 VGND VGND VPWR VPWR sky130_fd_sc_hd__decap_3
XFILLER_59_211 VGND VGND VPWR VPWR sky130_fd_sc_hd__fill_1
XFILLER_59_222 VGND VGND VPWR VPWR sky130_fd_sc_hd__fill_2
XFILLER_86_27 VGND VGND VPWR VPWR sky130_fd_sc_hd__fill_1
XFILLER_87_520 VGND VGND VPWR VPWR sky130_fd_sc_hd__decap_3
XFILLER_19_21 VGND VGND VPWR VPWR sky130_fd_sc_hd__fill_2
XFILLER_87_553 VGND VGND VPWR VPWR sky130_fd_sc_hd__decap_3
XFILLER_87_564 VGND VGND VPWR VPWR sky130_fd_sc_hd__fill_1
X_7109_ _7370_/CLK _7109_/D _6389_/Y VGND VGND VPWR VPWR _7109_/Q sky130_fd_sc_hd__dfrtp_2
XFILLER_99_391 VGND VGND VPWR VPWR sky130_fd_sc_hd__fill_1
XFILLER_101_352 VGND VGND VPWR VPWR sky130_fd_sc_hd__decap_3
XFILLER_19_119 VGND VGND VPWR VPWR sky130_fd_sc_hd__decap_3
XFILLER_19_43 VGND VGND VPWR VPWR sky130_fd_sc_hd__decap_3
XFILLER_19_65 VGND VGND VPWR VPWR sky130_fd_sc_hd__fill_1
XFILLER_59_266 VGND VGND VPWR VPWR sky130_fd_sc_hd__decap_3
XFILLER_74_203 VGND VGND VPWR VPWR sky130_fd_sc_hd__decap_3
XFILLER_87_586 VGND VGND VPWR VPWR sky130_fd_sc_hd__decap_3
XFILLER_101_396 VGND VGND VPWR VPWR sky130_fd_sc_hd__decap_3
XFILLER_28_631 VGND VGND VPWR VPWR sky130_fd_sc_hd__decap_3
XFILLER_74_225 VGND VGND VPWR VPWR sky130_fd_sc_hd__decap_3
XFILLER_74_247 VGND VGND VPWR VPWR sky130_fd_sc_hd__decap_3
XFILLER_27_152 VGND VGND VPWR VPWR sky130_fd_sc_hd__fill_2
XFILLER_28_675 VGND VGND VPWR VPWR sky130_fd_sc_hd__decap_3
XFILLER_90_707 VGND VGND VPWR VPWR sky130_fd_sc_hd__decap_3
XTAP_TAPCELL_ROW_87_1351 VGND VPWR sky130_fd_sc_hd__tapvpwrvgnd_1
XTAP_TAPCELL_ROW_87_1340 VGND VPWR sky130_fd_sc_hd__tapvpwrvgnd_1
XTAP_TAPCELL_ROW_58_979 VGND VPWR sky130_fd_sc_hd__tapvpwrvgnd_1
XFILLER_15_314 VGND VGND VPWR VPWR sky130_fd_sc_hd__decap_3
XFILLER_43_612 VGND VGND VPWR VPWR sky130_fd_sc_hd__decap_3
XFILLER_43_623 VGND VGND VPWR VPWR sky130_fd_sc_hd__decap_3
XTAP_TAPCELL_ROW_2_284 VGND VPWR sky130_fd_sc_hd__tapvpwrvgnd_1
XFILLER_35_75 VGND VGND VPWR VPWR sky130_fd_sc_hd__fill_1
XFILLER_42_144 VGND VGND VPWR VPWR sky130_fd_sc_hd__decap_3
XFILLER_43_656 VGND VGND VPWR VPWR sky130_fd_sc_hd__decap_3
XFILLER_42_155 VGND VGND VPWR VPWR sky130_fd_sc_hd__decap_3
XFILLER_30_339 VGND VGND VPWR VPWR sky130_fd_sc_hd__decap_3
XFILLER_11_564 VGND VGND VPWR VPWR sky130_fd_sc_hd__decap_3
XFILLER_11_597 VGND VGND VPWR VPWR sky130_fd_sc_hd__decap_3
XFILLER_7_557 VGND VGND VPWR VPWR sky130_fd_sc_hd__decap_3
XFILLER_109_452 VGND VGND VPWR VPWR sky130_fd_sc_hd__fill_1
XFILLER_7_579 VGND VGND VPWR VPWR sky130_fd_sc_hd__decap_3
XTAP_TAPCELL_ROW_98_1480 VGND VPWR sky130_fd_sc_hd__tapvpwrvgnd_1
XFILLER_105_691 VGND VGND VPWR VPWR sky130_fd_sc_hd__decap_3
XFILLER_111_116 VGND VGND VPWR VPWR sky130_fd_sc_hd__decap_3
XFILLER_111_127 VGND VGND VPWR VPWR sky130_fd_sc_hd__decap_3
XFILLER_112_628 VGND VGND VPWR VPWR sky130_fd_sc_hd__decap_3
XFILLER_78_520 VGND VGND VPWR VPWR sky130_fd_sc_hd__decap_3
XFILLER_111_138 VGND VGND VPWR VPWR sky130_fd_sc_hd__decap_3
XFILLER_66_704 VGND VGND VPWR VPWR sky130_fd_sc_hd__decap_3
XFILLER_78_542 VGND VGND VPWR VPWR sky130_fd_sc_hd__decap_3
XFILLER_19_620 VGND VGND VPWR VPWR sky130_fd_sc_hd__decap_3
XFILLER_18_141 VGND VGND VPWR VPWR sky130_fd_sc_hd__fill_1
XFILLER_19_653 VGND VGND VPWR VPWR sky130_fd_sc_hd__decap_3
XFILLER_34_601 VGND VGND VPWR VPWR sky130_fd_sc_hd__decap_3
XFILLER_46_450 VGND VGND VPWR VPWR sky130_fd_sc_hd__decap_3
XFILLER_65_258 VGND VGND VPWR VPWR sky130_fd_sc_hd__decap_3
XFILLER_80_206 VGND VGND VPWR VPWR sky130_fd_sc_hd__fill_1
XFILLER_18_185 VGND VGND VPWR VPWR sky130_fd_sc_hd__decap_3
XFILLER_19_697 VGND VGND VPWR VPWR sky130_fd_sc_hd__decap_3
XFILLER_34_634 VGND VGND VPWR VPWR sky130_fd_sc_hd__decap_3
XFILLER_46_483 VGND VGND VPWR VPWR sky130_fd_sc_hd__decap_3
XFILLER_80_228 VGND VGND VPWR VPWR sky130_fd_sc_hd__decap_3
XFILLER_34_645 VGND VGND VPWR VPWR sky130_fd_sc_hd__decap_3
XFILLER_34_678 VGND VGND VPWR VPWR sky130_fd_sc_hd__decap_3
XFILLER_61_442 VGND VGND VPWR VPWR sky130_fd_sc_hd__decap_3
X_4810_ _4813_/A _4810_/B _4829_/B VGND VGND VPWR VPWR _4810_/X sky130_fd_sc_hd__or3_2
XFILLER_33_166 VGND VGND VPWR VPWR sky130_fd_sc_hd__fill_2
XFILLER_61_486 VGND VGND VPWR VPWR sky130_fd_sc_hd__decap_3
X_4741_ _4761_/B _4761_/C _4762_/B VGND VGND VPWR VPWR _4741_/X sky130_fd_sc_hd__a21o_2
XTAP_TAPCELL_ROW_60_1012 VGND VPWR sky130_fd_sc_hd__tapvpwrvgnd_1
XFILLER_119_216 VGND VGND VPWR VPWR sky130_fd_sc_hd__decap_3
X_4672_ _6991_/Q _4690_/B VGND VGND VPWR VPWR _4673_/B sky130_fd_sc_hd__nor2_2
X_6411_ _6636_/A VGND VGND VPWR VPWR _6411_/Y sky130_fd_sc_hd__inv_2
X_7391_ _7396_/CLK _7391_/D _6671_/Y VGND VGND VPWR VPWR _7391_/Q sky130_fd_sc_hd__dfrtp_2
XFILLER_115_433 VGND VGND VPWR VPWR sky130_fd_sc_hd__decap_3
X_6342_ _6533_/A VGND VGND VPWR VPWR _6342_/Y sky130_fd_sc_hd__inv_2
X_3554_ _7317_/Q _3994_/S _4285_/B1 _7349_/Q VGND VGND VPWR VPWR _3556_/B sky130_fd_sc_hd__a22o_2
XFILLER_103_606 VGND VGND VPWR VPWR sky130_fd_sc_hd__decap_3
XFILLER_103_617 VGND VGND VPWR VPWR sky130_fd_sc_hd__decap_3
XFILLER_115_444 VGND VGND VPWR VPWR sky130_fd_sc_hd__decap_3
XFILLER_115_466 VGND VGND VPWR VPWR sky130_fd_sc_hd__fill_1
X_6273_ _6676_/A VGND VGND VPWR VPWR _6273_/Y sky130_fd_sc_hd__inv_2
X_3485_ _3502_/A _3502_/B _3485_/C VGND VGND VPWR VPWR _5144_/A sky130_fd_sc_hd__or3_4
XFILLER_102_127 VGND VGND VPWR VPWR sky130_fd_sc_hd__decap_3
XFILLER_115_488 VGND VGND VPWR VPWR sky130_fd_sc_hd__decap_3
XTAP_TAPCELL_ROW_71_1141 VGND VPWR sky130_fd_sc_hd__tapvpwrvgnd_1
XFILLER_111_650 VGND VGND VPWR VPWR sky130_fd_sc_hd__decap_3
XFILLER_29_417 VGND VGND VPWR VPWR sky130_fd_sc_hd__decap_3
XFILLER_69_564 VGND VGND VPWR VPWR sky130_fd_sc_hd__fill_1
X_5155_ _4467_/B _3923_/X _5151_/X _5154_/Y VGND VGND VPWR VPWR _5155_/X sky130_fd_sc_hd__a31o_2
XFILLER_110_160 VGND VGND VPWR VPWR sky130_fd_sc_hd__decap_3
XFILLER_110_171 VGND VGND VPWR VPWR sky130_fd_sc_hd__decap_3
XFILLER_111_694 VGND VGND VPWR VPWR sky130_fd_sc_hd__decap_3
XFILLER_96_383 VGND VGND VPWR VPWR sky130_fd_sc_hd__decap_3
X_5086_ _5086_/A _5101_/B _5100_/B VGND VGND VPWR VPWR _5086_/X sky130_fd_sc_hd__and3_2
X_4106_ _7141_/Q _4351_/B1 _4103_/X _4105_/X VGND VGND VPWR VPWR _4106_/X sky130_fd_sc_hd__a211o_2
XFILLER_25_601 VGND VGND VPWR VPWR sky130_fd_sc_hd__decap_3
XFILLER_72_707 VGND VGND VPWR VPWR sky130_fd_sc_hd__decap_3
X_4037_ _4394_/A _4394_/B _4036_/X VGND VGND VPWR VPWR _4458_/A sky130_fd_sc_hd__or3b_2
XFILLER_112_47 VGND VGND VPWR VPWR sky130_fd_sc_hd__decap_3
XFILLER_25_623 VGND VGND VPWR VPWR sky130_fd_sc_hd__decap_3
XFILLER_37_472 VGND VGND VPWR VPWR sky130_fd_sc_hd__fill_2
XFILLER_37_494 VGND VGND VPWR VPWR sky130_fd_sc_hd__decap_3
XFILLER_64_280 VGND VGND VPWR VPWR sky130_fd_sc_hd__decap_3
XFILLER_71_217 VGND VGND VPWR VPWR sky130_fd_sc_hd__decap_3
XFILLER_71_228 VGND VGND VPWR VPWR sky130_fd_sc_hd__decap_3
XTAP_TAPCELL_ROW_55_949 VGND VPWR sky130_fd_sc_hd__tapvpwrvgnd_1
XFILLER_24_144 VGND VGND VPWR VPWR sky130_fd_sc_hd__decap_3
XFILLER_25_656 VGND VGND VPWR VPWR sky130_fd_sc_hd__decap_3
XFILLER_72_29 VGND VGND VPWR VPWR sky130_fd_sc_hd__decap_3
XFILLER_24_177 VGND VGND VPWR VPWR sky130_fd_sc_hd__decap_3
XFILLER_40_604 VGND VGND VPWR VPWR sky130_fd_sc_hd__decap_3
XFILLER_52_464 VGND VGND VPWR VPWR sky130_fd_sc_hd__decap_3
XFILLER_52_486 VGND VGND VPWR VPWR sky130_fd_sc_hd__decap_3
XFILLER_12_339 VGND VGND VPWR VPWR sky130_fd_sc_hd__decap_3
XFILLER_40_637 VGND VGND VPWR VPWR sky130_fd_sc_hd__decap_3
XFILLER_40_648 VGND VGND VPWR VPWR sky130_fd_sc_hd__decap_3
X_4939_ _4764_/B _4379_/B _4938_/Y _4937_/A _4852_/A VGND VGND VPWR VPWR _4939_/X
+ sky130_fd_sc_hd__o32a_2
XTAP_TAPCELL_ROW_82_1281 VGND VPWR sky130_fd_sc_hd__tapvpwrvgnd_1
XTAP_TAPCELL_ROW_35_695 VGND VPWR sky130_fd_sc_hd__tapvpwrvgnd_1
X_6609_ _6613_/A VGND VGND VPWR VPWR _6609_/Y sky130_fd_sc_hd__inv_2
XFILLER_21_55 VGND VGND VPWR VPWR sky130_fd_sc_hd__fill_1
XFILLER_106_433 VGND VGND VPWR VPWR sky130_fd_sc_hd__decap_3
XFILLER_21_66 VGND VGND VPWR VPWR sky130_fd_sc_hd__decap_3
XFILLER_4_527 VGND VGND VPWR VPWR sky130_fd_sc_hd__decap_3
XFILLER_79_306 VGND VGND VPWR VPWR sky130_fd_sc_hd__fill_2
XFILLER_106_477 VGND VGND VPWR VPWR sky130_fd_sc_hd__fill_2
XFILLER_106_488 VGND VGND VPWR VPWR sky130_fd_sc_hd__decap_3
XFILLER_97_48 VGND VGND VPWR VPWR sky130_fd_sc_hd__decap_3
XTAP_TAPCELL_ROW_7_343 VGND VPWR sky130_fd_sc_hd__tapvpwrvgnd_1
XFILLER_102_672 VGND VGND VPWR VPWR sky130_fd_sc_hd__decap_3
XFILLER_48_704 VGND VGND VPWR VPWR sky130_fd_sc_hd__decap_3
XFILLER_87_361 VGND VGND VPWR VPWR sky130_fd_sc_hd__decap_3
XFILLER_94_309 VGND VGND VPWR VPWR sky130_fd_sc_hd__decap_3
XFILLER_47_214 VGND VGND VPWR VPWR sky130_fd_sc_hd__decap_3
XFILLER_47_225 VGND VGND VPWR VPWR sky130_fd_sc_hd__decap_3
XFILLER_101_193 VGND VGND VPWR VPWR sky130_fd_sc_hd__decap_3
XFILLER_46_41 VGND VGND VPWR VPWR sky130_fd_sc_hd__fill_1
XFILLER_75_589 VGND VGND VPWR VPWR sky130_fd_sc_hd__decap_3
XFILLER_90_504 VGND VGND VPWR VPWR sky130_fd_sc_hd__decap_3
XFILLER_16_601 VGND VGND VPWR VPWR sky130_fd_sc_hd__decap_3
XFILLER_16_634 VGND VGND VPWR VPWR sky130_fd_sc_hd__decap_3
XFILLER_28_472 VGND VGND VPWR VPWR sky130_fd_sc_hd__decap_3
XFILLER_28_483 VGND VGND VPWR VPWR sky130_fd_sc_hd__decap_3
XFILLER_46_85 VGND VGND VPWR VPWR sky130_fd_sc_hd__decap_3
XFILLER_15_111 VGND VGND VPWR VPWR sky130_fd_sc_hd__fill_1
XFILLER_16_645 VGND VGND VPWR VPWR sky130_fd_sc_hd__decap_3
XFILLER_43_431 VGND VGND VPWR VPWR sky130_fd_sc_hd__decap_3
XFILLER_102_91 VGND VGND VPWR VPWR sky130_fd_sc_hd__decap_3
XFILLER_16_678 VGND VGND VPWR VPWR sky130_fd_sc_hd__decap_3
XFILLER_31_604 VGND VGND VPWR VPWR sky130_fd_sc_hd__decap_3
XFILLER_31_626 VGND VGND VPWR VPWR sky130_fd_sc_hd__decap_3
XFILLER_43_464 VGND VGND VPWR VPWR sky130_fd_sc_hd__decap_3
XFILLER_70_261 VGND VGND VPWR VPWR sky130_fd_sc_hd__decap_3
XFILLER_30_136 VGND VGND VPWR VPWR sky130_fd_sc_hd__decap_3
XFILLER_31_659 VGND VGND VPWR VPWR sky130_fd_sc_hd__decap_3
XFILLER_70_283 VGND VGND VPWR VPWR sky130_fd_sc_hd__decap_3
XFILLER_117_709 VGND VGND VPWR VPWR sky130_fd_sc_hd__decap_3
XFILLER_7_35 VGND VGND VPWR VPWR sky130_fd_sc_hd__decap_3
XFILLER_7_343 VGND VGND VPWR VPWR sky130_fd_sc_hd__decap_3
XFILLER_7_57 VGND VGND VPWR VPWR sky130_fd_sc_hd__fill_1
XFILLER_109_293 VGND VGND VPWR VPWR sky130_fd_sc_hd__decap_3
XFILLER_7_376 VGND VGND VPWR VPWR sky130_fd_sc_hd__decap_3
XFILLER_98_615 VGND VGND VPWR VPWR sky130_fd_sc_hd__decap_3
XFILLER_3_582 VGND VGND VPWR VPWR sky130_fd_sc_hd__decap_3
XFILLER_97_103 VGND VGND VPWR VPWR sky130_fd_sc_hd__fill_2
XFILLER_98_648 VGND VGND VPWR VPWR sky130_fd_sc_hd__decap_3
XFILLER_112_447 VGND VGND VPWR VPWR sky130_fd_sc_hd__fill_1
XFILLER_97_147 VGND VGND VPWR VPWR sky130_fd_sc_hd__fill_1
XFILLER_87_81 VGND VGND VPWR VPWR sky130_fd_sc_hd__decap_3
XFILLER_16_3 VGND VGND VPWR VPWR sky130_fd_sc_hd__fill_1
XFILLER_66_523 VGND VGND VPWR VPWR sky130_fd_sc_hd__fill_1
XFILLER_66_545 VGND VGND VPWR VPWR sky130_fd_sc_hd__decap_3
XFILLER_93_320 VGND VGND VPWR VPWR sky130_fd_sc_hd__fill_1
XFILLER_54_707 VGND VGND VPWR VPWR sky130_fd_sc_hd__decap_3
XFILLER_66_589 VGND VGND VPWR VPWR sky130_fd_sc_hd__decap_3
X_6960_ _6968_/CLK _6960_/D VGND VGND VPWR VPWR _6960_/Q sky130_fd_sc_hd__dfxtp_2
XFILLER_53_206 VGND VGND VPWR VPWR sky130_fd_sc_hd__decap_3
XFILLER_53_228 VGND VGND VPWR VPWR sky130_fd_sc_hd__decap_3
XFILLER_46_280 VGND VGND VPWR VPWR sky130_fd_sc_hd__decap_3
X_6891_ _6941_/CLK _6891_/D VGND VGND VPWR VPWR _6891_/Q sky130_fd_sc_hd__dfxtp_2
XTAP_TAPCELL_ROW_52_908 VGND VPWR sky130_fd_sc_hd__tapvpwrvgnd_1
XFILLER_21_103 VGND VGND VPWR VPWR sky130_fd_sc_hd__decap_3
XFILLER_22_604 VGND VGND VPWR VPWR sky130_fd_sc_hd__decap_3
XFILLER_34_453 VGND VGND VPWR VPWR sky130_fd_sc_hd__fill_2
XFILLER_34_486 VGND VGND VPWR VPWR sky130_fd_sc_hd__decap_3
XTAP_TAPCELL_ROW_105_1568 VGND VPWR sky130_fd_sc_hd__tapvpwrvgnd_1
XFILLER_21_125 VGND VGND VPWR VPWR sky130_fd_sc_hd__decap_3
XFILLER_22_637 VGND VGND VPWR VPWR sky130_fd_sc_hd__decap_3
XFILLER_22_648 VGND VGND VPWR VPWR sky130_fd_sc_hd__decap_3
XFILLER_21_169 VGND VGND VPWR VPWR sky130_fd_sc_hd__decap_3
X_4724_ _4720_/A _4655_/X _4658_/B VGND VGND VPWR VPWR _4724_/X sky130_fd_sc_hd__o21a_2
XTAP_TAPCELL_ROW_32_654 VGND VPWR sky130_fd_sc_hd__tapvpwrvgnd_1
XFILLER_30_681 VGND VGND VPWR VPWR sky130_fd_sc_hd__decap_3
X_4655_ _4610_/A _4765_/B _4611_/Y _4762_/A _4744_/B VGND VGND VPWR VPWR _4655_/X
+ sky130_fd_sc_hd__a221o_2
X_7374_ _7374_/CLK _7374_/D _6654_/Y VGND VGND VPWR VPWR _7374_/Q sky130_fd_sc_hd__dfrtp_2
Xhold800 _6767_/Q VGND VGND VPWR VPWR _6767_/D sky130_fd_sc_hd__dlygate4sd3_1
Xhold811 _6815_/Q VGND VGND VPWR VPWR _6815_/D sky130_fd_sc_hd__dlygate4sd3_1
X_3606_ _4614_/B _3603_/B _5103_/A1 VGND VGND VPWR VPWR _3606_/X sky130_fd_sc_hd__o21a_2
XFILLER_1_508 VGND VGND VPWR VPWR sky130_fd_sc_hd__decap_3
XFILLER_89_604 VGND VGND VPWR VPWR sky130_fd_sc_hd__fill_2
Xhold822 _6776_/Q VGND VGND VPWR VPWR _6776_/D sky130_fd_sc_hd__dlygate4sd3_1
Xhold833 _6933_/Q VGND VGND VPWR VPWR _6933_/D sky130_fd_sc_hd__dlygate4sd3_1
Xhold844 _6965_/Q VGND VGND VPWR VPWR _6965_/D sky130_fd_sc_hd__dlygate4sd3_1
Xhold855 _6756_/Q VGND VGND VPWR VPWR _6756_/D sky130_fd_sc_hd__dlygate4sd3_1
X_6325_ _6671_/A VGND VGND VPWR VPWR _6325_/Y sky130_fd_sc_hd__inv_2
X_3537_ _3427_/B _4764_/B _5057_/A _3527_/A _3536_/Y VGND VGND VPWR VPWR _3537_/X
+ sky130_fd_sc_hd__o221a_2
XFILLER_107_47 VGND VGND VPWR VPWR sky130_fd_sc_hd__fill_1
XFILLER_115_252 VGND VGND VPWR VPWR sky130_fd_sc_hd__decap_3
XFILLER_88_103 VGND VGND VPWR VPWR sky130_fd_sc_hd__fill_2
XFILLER_89_626 VGND VGND VPWR VPWR sky130_fd_sc_hd__decap_3
Xhold866 _6916_/Q VGND VGND VPWR VPWR _6916_/D sky130_fd_sc_hd__dlygate4sd3_1
Xhold877 _6863_/Q VGND VGND VPWR VPWR _6863_/D sky130_fd_sc_hd__dlygate4sd3_1
Xhold888 _6926_/Q VGND VGND VPWR VPWR _6926_/D sky130_fd_sc_hd__dlygate4sd3_1
XFILLER_103_447 VGND VGND VPWR VPWR sky130_fd_sc_hd__fill_1
XFILLER_103_458 VGND VGND VPWR VPWR sky130_fd_sc_hd__decap_3
XFILLER_107_69 VGND VGND VPWR VPWR sky130_fd_sc_hd__decap_3
XFILLER_88_147 VGND VGND VPWR VPWR sky130_fd_sc_hd__decap_3
XFILLER_89_659 VGND VGND VPWR VPWR sky130_fd_sc_hd__decap_3
Xhold899 _6890_/Q VGND VGND VPWR VPWR _6890_/D sky130_fd_sc_hd__dlygate4sd3_1
X_3468_ _7281_/Q _5142_/S _3417_/X _7089_/Q _3467_/X VGND VGND VPWR VPWR _3468_/X
+ sky130_fd_sc_hd__a221o_2
XFILLER_57_501 VGND VGND VPWR VPWR sky130_fd_sc_hd__decap_3
XFILLER_69_361 VGND VGND VPWR VPWR sky130_fd_sc_hd__decap_3
X_5207_ _5207_/A _5207_/B VGND VGND VPWR VPWR _7225_/D sky130_fd_sc_hd__and2_2
X_3399_ _3994_/S _3399_/B VGND VGND VPWR VPWR _3449_/B sky130_fd_sc_hd__nor2_4
XTAP_TAPCELL_ROW_4_313 VGND VPWR sky130_fd_sc_hd__tapvpwrvgnd_1
XTAP_TAPCELL_ROW_4_302 VGND VPWR sky130_fd_sc_hd__tapvpwrvgnd_1
XFILLER_111_480 VGND VGND VPWR VPWR sky130_fd_sc_hd__decap_3
XFILLER_29_214 VGND VGND VPWR VPWR sky130_fd_sc_hd__decap_3
XFILLER_29_225 VGND VGND VPWR VPWR sky130_fd_sc_hd__decap_3
XFILLER_57_545 VGND VGND VPWR VPWR sky130_fd_sc_hd__decap_3
XFILLER_96_180 VGND VGND VPWR VPWR sky130_fd_sc_hd__decap_3
X_5138_ _3661_/B _3914_/X _5151_/A VGND VGND VPWR VPWR _5138_/X sky130_fd_sc_hd__mux2_2
XFILLER_29_258 VGND VGND VPWR VPWR sky130_fd_sc_hd__decap_3
XFILLER_72_504 VGND VGND VPWR VPWR sky130_fd_sc_hd__decap_3
XFILLER_84_353 VGND VGND VPWR VPWR sky130_fd_sc_hd__decap_3
XFILLER_57_589 VGND VGND VPWR VPWR sky130_fd_sc_hd__decap_3
XFILLER_83_28 VGND VGND VPWR VPWR sky130_fd_sc_hd__decap_3
X_5069_ _6987_/Q _5069_/B VGND VGND VPWR VPWR _5069_/X sky130_fd_sc_hd__or2_2
XTAP_TAPCELL_ROW_84_1310 VGND VPWR sky130_fd_sc_hd__tapvpwrvgnd_1
XFILLER_25_420 VGND VGND VPWR VPWR sky130_fd_sc_hd__fill_2
XFILLER_13_615 VGND VGND VPWR VPWR sky130_fd_sc_hd__fill_1
XFILLER_13_626 VGND VGND VPWR VPWR sky130_fd_sc_hd__decap_3
XFILLER_13_659 VGND VGND VPWR VPWR sky130_fd_sc_hd__decap_3
XFILLER_52_294 VGND VGND VPWR VPWR sky130_fd_sc_hd__decap_3
XFILLER_80_592 VGND VGND VPWR VPWR sky130_fd_sc_hd__decap_3
XFILLER_40_489 VGND VGND VPWR VPWR sky130_fd_sc_hd__decap_3
XFILLER_106_241 VGND VGND VPWR VPWR sky130_fd_sc_hd__decap_3
XFILLER_4_346 VGND VGND VPWR VPWR sky130_fd_sc_hd__fill_2
XTAP_TAPCELL_ROW_95_1450 VGND VPWR sky130_fd_sc_hd__tapvpwrvgnd_1
XFILLER_106_274 VGND VGND VPWR VPWR sky130_fd_sc_hd__decap_3
XFILLER_4_379 VGND VGND VPWR VPWR sky130_fd_sc_hd__decap_3
XFILLER_79_125 VGND VGND VPWR VPWR sky130_fd_sc_hd__decap_3
XFILLER_95_607 VGND VGND VPWR VPWR sky130_fd_sc_hd__decap_3
XFILLER_0_552 VGND VGND VPWR VPWR sky130_fd_sc_hd__decap_3
XFILLER_79_169 VGND VGND VPWR VPWR sky130_fd_sc_hd__decap_3
XFILLER_94_106 VGND VGND VPWR VPWR sky130_fd_sc_hd__decap_3
XFILLER_95_629 VGND VGND VPWR VPWR sky130_fd_sc_hd__decap_3
XFILLER_0_585 VGND VGND VPWR VPWR sky130_fd_sc_hd__decap_3
XFILLER_102_480 VGND VGND VPWR VPWR sky130_fd_sc_hd__decap_3
XFILLER_57_51 VGND VGND VPWR VPWR sky130_fd_sc_hd__decap_3
XFILLER_88_681 VGND VGND VPWR VPWR sky130_fd_sc_hd__decap_3
XFILLER_94_139 VGND VGND VPWR VPWR sky130_fd_sc_hd__fill_1
XFILLER_36_707 VGND VGND VPWR VPWR sky130_fd_sc_hd__decap_3
XFILLER_48_567 VGND VGND VPWR VPWR sky130_fd_sc_hd__decap_3
XFILLER_75_353 VGND VGND VPWR VPWR sky130_fd_sc_hd__decap_3
XFILLER_35_228 VGND VGND VPWR VPWR sky130_fd_sc_hd__decap_3
XFILLER_63_526 VGND VGND VPWR VPWR sky130_fd_sc_hd__decap_3
XFILLER_90_301 VGND VGND VPWR VPWR sky130_fd_sc_hd__fill_2
XFILLER_90_312 VGND VGND VPWR VPWR sky130_fd_sc_hd__decap_3
Xplace504 _6983_/Q VGND VGND VPWR VPWR _3561_/B sky130_fd_sc_hd__buf_2
XFILLER_113_90 VGND VGND VPWR VPWR sky130_fd_sc_hd__decap_3
XFILLER_16_442 VGND VGND VPWR VPWR sky130_fd_sc_hd__decap_3
XFILLER_28_291 VGND VGND VPWR VPWR sky130_fd_sc_hd__decap_3
Xplace515 _6557_/A VGND VGND VPWR VPWR _6556_/A sky130_fd_sc_hd__buf_2
Xplace526 _6617_/A VGND VGND VPWR VPWR _6651_/A sky130_fd_sc_hd__buf_2
Xplace537 _6667_/A VGND VGND VPWR VPWR _6544_/A sky130_fd_sc_hd__buf_2
XFILLER_43_250 VGND VGND VPWR VPWR sky130_fd_sc_hd__decap_3
XFILLER_73_83 VGND VGND VPWR VPWR sky130_fd_sc_hd__decap_3
Xplace548 place571/A VGND VGND VPWR VPWR _6654_/A sky130_fd_sc_hd__buf_2
Xplace559 _6632_/A VGND VGND VPWR VPWR _6624_/A sky130_fd_sc_hd__buf_2
XFILLER_12_681 VGND VGND VPWR VPWR sky130_fd_sc_hd__decap_3
XFILLER_117_517 VGND VGND VPWR VPWR sky130_fd_sc_hd__fill_1
XFILLER_8_663 VGND VGND VPWR VPWR sky130_fd_sc_hd__decap_3
XFILLER_117_539 VGND VGND VPWR VPWR sky130_fd_sc_hd__decap_3
XFILLER_7_162 VGND VGND VPWR VPWR sky130_fd_sc_hd__decap_3
XFILLER_8_696 VGND VGND VPWR VPWR sky130_fd_sc_hd__decap_3
X_4440_ _4440_/A _4650_/B VGND VGND VPWR VPWR _4441_/B sky130_fd_sc_hd__nand2_2
XFILLER_112_200 VGND VGND VPWR VPWR sky130_fd_sc_hd__fill_1
XFILLER_113_712 VGND VGND VPWR VPWR sky130_fd_sc_hd__fill_2
X_4371_ _4371_/A _4371_/B VGND VGND VPWR VPWR _4371_/Y sky130_fd_sc_hd__nand2_2
XFILLER_98_80 VGND VGND VPWR VPWR sky130_fd_sc_hd__decap_3
X_7090_ _7355_/CLK _7090_/D _6370_/Y VGND VGND VPWR VPWR _7090_/Q sky130_fd_sc_hd__dfrtp_2
XFILLER_100_417 VGND VGND VPWR VPWR sky130_fd_sc_hd__decap_3
XFILLER_112_277 VGND VGND VPWR VPWR sky130_fd_sc_hd__decap_3
XFILLER_86_629 VGND VGND VPWR VPWR sky130_fd_sc_hd__decap_3
XFILLER_98_489 VGND VGND VPWR VPWR sky130_fd_sc_hd__fill_2
XFILLER_39_523 VGND VGND VPWR VPWR sky130_fd_sc_hd__decap_3
XFILLER_85_128 VGND VGND VPWR VPWR sky130_fd_sc_hd__decap_3
XFILLER_66_331 VGND VGND VPWR VPWR sky130_fd_sc_hd__decap_3
XFILLER_94_640 VGND VGND VPWR VPWR sky130_fd_sc_hd__decap_3
XFILLER_94_651 VGND VGND VPWR VPWR sky130_fd_sc_hd__decap_3
XFILLER_26_206 VGND VGND VPWR VPWR sky130_fd_sc_hd__decap_3
XFILLER_66_386 VGND VGND VPWR VPWR sky130_fd_sc_hd__fill_1
XFILLER_93_172 VGND VGND VPWR VPWR sky130_fd_sc_hd__decap_3
XFILLER_94_684 VGND VGND VPWR VPWR sky130_fd_sc_hd__decap_3
XTAP_TAPCELL_ROW_37_724 VGND VPWR sky130_fd_sc_hd__tapvpwrvgnd_1
XFILLER_54_548 VGND VGND VPWR VPWR sky130_fd_sc_hd__decap_3
XFILLER_81_345 VGND VGND VPWR VPWR sky130_fd_sc_hd__fill_1
X_6943_ _6943_/CLK _6943_/D VGND VGND VPWR VPWR _6943_/Q sky130_fd_sc_hd__dfxtp_2
XFILLER_34_250 VGND VGND VPWR VPWR sky130_fd_sc_hd__fill_2
XFILLER_50_710 VGND VGND VPWR VPWR sky130_fd_sc_hd__decap_3
XFILLER_81_389 VGND VGND VPWR VPWR sky130_fd_sc_hd__decap_3
X_6874_ _6922_/CLK _6874_/D VGND VGND VPWR VPWR _6874_/Q sky130_fd_sc_hd__dfxtp_2
XFILLER_62_592 VGND VGND VPWR VPWR sky130_fd_sc_hd__fill_1
XTAP_TAPCELL_ROW_66_1084 VGND VPWR sky130_fd_sc_hd__tapvpwrvgnd_1
XTAP_TAPCELL_ROW_17_470 VGND VPWR sky130_fd_sc_hd__tapvpwrvgnd_1
XFILLER_10_607 VGND VGND VPWR VPWR sky130_fd_sc_hd__decap_3
XFILLER_22_489 VGND VGND VPWR VPWR sky130_fd_sc_hd__fill_1
XFILLER_108_517 VGND VGND VPWR VPWR sky130_fd_sc_hd__decap_3
X_4707_ _6998_/Q _6999_/Q _7000_/Q _4912_/A VGND VGND VPWR VPWR _4825_/B sky130_fd_sc_hd__and4_2
XTAP_TAPCELL_ROW_118_1737 VGND VPWR sky130_fd_sc_hd__tapvpwrvgnd_1
X_4638_ _4950_/A _4950_/B VGND VGND VPWR VPWR _4948_/B sky130_fd_sc_hd__and2_2
XFILLER_116_550 VGND VGND VPWR VPWR sky130_fd_sc_hd__decap_3
XFILLER_118_35 VGND VGND VPWR VPWR sky130_fd_sc_hd__decap_3
XFILLER_104_701 VGND VGND VPWR VPWR sky130_fd_sc_hd__decap_3
XFILLER_118_68 VGND VGND VPWR VPWR sky130_fd_sc_hd__decap_3
XFILLER_89_412 VGND VGND VPWR VPWR sky130_fd_sc_hd__decap_3
X_7357_ _7357_/CLK _7357_/D _6637_/Y VGND VGND VPWR VPWR _7357_/Q sky130_fd_sc_hd__dfrtp_2
X_4569_ _4569_/A _4577_/B VGND VGND VPWR VPWR _7296_/D sky130_fd_sc_hd__and2_2
XFILLER_103_211 VGND VGND VPWR VPWR sky130_fd_sc_hd__decap_3
XFILLER_1_327 VGND VGND VPWR VPWR sky130_fd_sc_hd__decap_3
X_7288_ _7355_/CLK _7288_/D _6568_/Y VGND VGND VPWR VPWR _7288_/Q sky130_fd_sc_hd__dfrtp_2
Xhold685 _6932_/Q VGND VGND VPWR VPWR _6932_/D sky130_fd_sc_hd__dlygate4sd3_1
Xhold696 _6896_/Q VGND VGND VPWR VPWR _6896_/D sky130_fd_sc_hd__dlygate4sd3_1
X_6308_ _6662_/A VGND VGND VPWR VPWR _6308_/Y sky130_fd_sc_hd__inv_2
XFILLER_103_255 VGND VGND VPWR VPWR sky130_fd_sc_hd__decap_3
XFILLER_77_629 VGND VGND VPWR VPWR sky130_fd_sc_hd__decap_3
XFILLER_89_489 VGND VGND VPWR VPWR sky130_fd_sc_hd__decap_3
XTAP_TAPCELL_ROW_90_1380 VGND VPWR sky130_fd_sc_hd__tapvpwrvgnd_1
XFILLER_18_707 VGND VGND VPWR VPWR sky130_fd_sc_hd__decap_3
XFILLER_57_331 VGND VGND VPWR VPWR sky130_fd_sc_hd__decap_3
XFILLER_85_662 VGND VGND VPWR VPWR sky130_fd_sc_hd__decap_3
XFILLER_94_38 VGND VGND VPWR VPWR sky130_fd_sc_hd__decap_3
XFILLER_17_206 VGND VGND VPWR VPWR sky130_fd_sc_hd__decap_3
XFILLER_17_217 VGND VGND VPWR VPWR sky130_fd_sc_hd__decap_3
XFILLER_72_312 VGND VGND VPWR VPWR sky130_fd_sc_hd__decap_3
XFILLER_85_673 VGND VGND VPWR VPWR sky130_fd_sc_hd__decap_3
XFILLER_27_76 VGND VGND VPWR VPWR sky130_fd_sc_hd__decap_3
XFILLER_45_559 VGND VGND VPWR VPWR sky130_fd_sc_hd__fill_1
XFILLER_84_194 VGND VGND VPWR VPWR sky130_fd_sc_hd__fill_2
XFILLER_60_518 VGND VGND VPWR VPWR sky130_fd_sc_hd__decap_3
XFILLER_13_412 VGND VGND VPWR VPWR sky130_fd_sc_hd__decap_3
XFILLER_53_570 VGND VGND VPWR VPWR sky130_fd_sc_hd__decap_3
XFILLER_13_467 VGND VGND VPWR VPWR sky130_fd_sc_hd__fill_1
XFILLER_40_242 VGND VGND VPWR VPWR sky130_fd_sc_hd__decap_3
XFILLER_9_405 VGND VGND VPWR VPWR sky130_fd_sc_hd__fill_1
XFILLER_40_286 VGND VGND VPWR VPWR sky130_fd_sc_hd__decap_3
XFILLER_9_449 VGND VGND VPWR VPWR sky130_fd_sc_hd__decap_3
XFILLER_5_600 VGND VGND VPWR VPWR sky130_fd_sc_hd__decap_3
XFILLER_5_644 VGND VGND VPWR VPWR sky130_fd_sc_hd__decap_3
XFILLER_107_561 VGND VGND VPWR VPWR sky130_fd_sc_hd__decap_3
XFILLER_107_572 VGND VGND VPWR VPWR sky130_fd_sc_hd__decap_3
XFILLER_107_583 VGND VGND VPWR VPWR sky130_fd_sc_hd__decap_3
XFILLER_5_688 VGND VGND VPWR VPWR sky130_fd_sc_hd__decap_3
XFILLER_110_704 VGND VGND VPWR VPWR sky130_fd_sc_hd__decap_3
XFILLER_68_618 VGND VGND VPWR VPWR sky130_fd_sc_hd__decap_3
XFILLER_0_360 VGND VGND VPWR VPWR sky130_fd_sc_hd__decap_3
XFILLER_67_139 VGND VGND VPWR VPWR sky130_fd_sc_hd__decap_3
XFILLER_95_426 VGND VGND VPWR VPWR sky130_fd_sc_hd__fill_1
XFILLER_0_393 VGND VGND VPWR VPWR sky130_fd_sc_hd__fill_1
XFILLER_76_651 VGND VGND VPWR VPWR sky130_fd_sc_hd__decap_3
XFILLER_75_150 VGND VGND VPWR VPWR sky130_fd_sc_hd__decap_3
XFILLER_75_172 VGND VGND VPWR VPWR sky130_fd_sc_hd__decap_3
XFILLER_76_684 VGND VGND VPWR VPWR sky130_fd_sc_hd__decap_3
XFILLER_82_109 VGND VGND VPWR VPWR sky130_fd_sc_hd__decap_3
XFILLER_91_610 VGND VGND VPWR VPWR sky130_fd_sc_hd__decap_3
XFILLER_63_334 VGND VGND VPWR VPWR sky130_fd_sc_hd__fill_2
XFILLER_84_60 VGND VGND VPWR VPWR sky130_fd_sc_hd__decap_3
XFILLER_91_632 VGND VGND VPWR VPWR sky130_fd_sc_hd__decap_3
XFILLER_51_529 VGND VGND VPWR VPWR sky130_fd_sc_hd__decap_3
XFILLER_90_153 VGND VGND VPWR VPWR sky130_fd_sc_hd__fill_2
XFILLER_91_665 VGND VGND VPWR VPWR sky130_fd_sc_hd__decap_3
XFILLER_91_676 VGND VGND VPWR VPWR sky130_fd_sc_hd__decap_3
Xplace345 _3656_/Y VGND VGND VPWR VPWR _3887_/A2 sky130_fd_sc_hd__buf_2
Xplace334 _3906_/A2 VGND VGND VPWR VPWR _3921_/A2 sky130_fd_sc_hd__buf_2
Xplace323 _3925_/B1 VGND VGND VPWR VPWR _3767_/B1 sky130_fd_sc_hd__buf_2
XFILLER_16_283 VGND VGND VPWR VPWR sky130_fd_sc_hd__decap_3
XFILLER_32_710 VGND VGND VPWR VPWR sky130_fd_sc_hd__decap_3
XFILLER_44_592 VGND VGND VPWR VPWR sky130_fd_sc_hd__decap_3
XFILLER_90_197 VGND VGND VPWR VPWR sky130_fd_sc_hd__decap_3
Xplace389 _3591_/A VGND VGND VPWR VPWR _4376_/A sky130_fd_sc_hd__buf_2
Xplace378 _4599_/S VGND VGND VPWR VPWR _4601_/S sky130_fd_sc_hd__buf_2
Xplace367 _4577_/B VGND VGND VPWR VPWR _4563_/B sky130_fd_sc_hd__buf_2
Xplace356 _3634_/Y VGND VGND VPWR VPWR _3991_/B sky130_fd_sc_hd__buf_2
XTAP_TAPCELL_ROW_102_1527 VGND VPWR sky130_fd_sc_hd__tapvpwrvgnd_1
XFILLER_31_220 VGND VGND VPWR VPWR sky130_fd_sc_hd__decap_3
XFILLER_31_231 VGND VGND VPWR VPWR sky130_fd_sc_hd__decap_3
X_3871_ _6785_/Q _3922_/A2 _3925_/B1 _6873_/Q VGND VGND VPWR VPWR _3871_/X sky130_fd_sc_hd__a22o_2
XTAP_TAPCELL_ROW_102_1538 VGND VPWR sky130_fd_sc_hd__tapvpwrvgnd_1
X_6590_ _6622_/A VGND VGND VPWR VPWR _6590_/Y sky130_fd_sc_hd__inv_2
XTAP_TAPCELL_ROW_42_782 VGND VPWR sky130_fd_sc_hd__tapvpwrvgnd_1
XFILLER_117_369 VGND VGND VPWR VPWR sky130_fd_sc_hd__fill_2
X_7211_ _7402_/CLK _7211_/D _6491_/Y VGND VGND VPWR VPWR _7211_/Q sky130_fd_sc_hd__dfrtp_2
X_4423_ _7080_/Q _4265_/B _4205_/A _4422_/X VGND VGND VPWR VPWR _4649_/B sky130_fd_sc_hd__o211ai_2
XFILLER_98_231 VGND VGND VPWR VPWR sky130_fd_sc_hd__decap_3
X_7142_ _7374_/CLK _7142_/D _6422_/Y VGND VGND VPWR VPWR _7142_/Q sky130_fd_sc_hd__dfrtp_2
X_4354_ _7038_/Q _4244_/B _4354_/B1 _7385_/Q VGND VGND VPWR VPWR _4355_/B sky130_fd_sc_hd__a22o_2
XTAP_TAPCELL_ROW_113_1667 VGND VPWR sky130_fd_sc_hd__tapvpwrvgnd_1
XFILLER_58_106 VGND VGND VPWR VPWR sky130_fd_sc_hd__decap_3
XFILLER_59_629 VGND VGND VPWR VPWR sky130_fd_sc_hd__decap_3
XFILLER_98_253 VGND VGND VPWR VPWR sky130_fd_sc_hd__decap_3
X_7073_ _7403_/CLK _7073_/D _6353_/Y VGND VGND VPWR VPWR _7073_/Q sky130_fd_sc_hd__dfrtp_2
X_3305_ _3561_/B VGND VGND VPWR VPWR _3340_/B sky130_fd_sc_hd__inv_2
XFILLER_100_203 VGND VGND VPWR VPWR sky130_fd_sc_hd__decap_3
XFILLER_113_597 VGND VGND VPWR VPWR sky130_fd_sc_hd__decap_3
XFILLER_58_128 VGND VGND VPWR VPWR sky130_fd_sc_hd__decap_3
XFILLER_86_448 VGND VGND VPWR VPWR sky130_fd_sc_hd__decap_3
XFILLER_98_297 VGND VGND VPWR VPWR sky130_fd_sc_hd__fill_1
X_4285_ _7035_/Q _4285_/A2 _4285_/B1 _7382_/Q VGND VGND VPWR VPWR _4286_/B sky130_fd_sc_hd__a22o_2
XFILLER_67_662 VGND VGND VPWR VPWR sky130_fd_sc_hd__decap_3
XFILLER_54_301 VGND VGND VPWR VPWR sky130_fd_sc_hd__decap_3
XFILLER_54_312 VGND VGND VPWR VPWR sky130_fd_sc_hd__decap_3
XFILLER_66_161 VGND VGND VPWR VPWR sky130_fd_sc_hd__decap_3
XFILLER_67_673 VGND VGND VPWR VPWR sky130_fd_sc_hd__decap_3
XFILLER_82_610 VGND VGND VPWR VPWR sky130_fd_sc_hd__decap_3
XTAP_TAPCELL_ROW_68_1113 VGND VPWR sky130_fd_sc_hd__tapvpwrvgnd_1
XTAP_TAPCELL_ROW_68_1102 VGND VPWR sky130_fd_sc_hd__tapvpwrvgnd_1
XFILLER_54_334 VGND VGND VPWR VPWR sky130_fd_sc_hd__fill_2
XFILLER_66_194 VGND VGND VPWR VPWR sky130_fd_sc_hd__fill_2
XFILLER_81_131 VGND VGND VPWR VPWR sky130_fd_sc_hd__decap_3
XFILLER_82_643 VGND VGND VPWR VPWR sky130_fd_sc_hd__fill_1
XFILLER_82_654 VGND VGND VPWR VPWR sky130_fd_sc_hd__decap_3
XFILLER_14_209 VGND VGND VPWR VPWR sky130_fd_sc_hd__decap_3
XFILLER_81_164 VGND VGND VPWR VPWR sky130_fd_sc_hd__decap_3
XFILLER_82_687 VGND VGND VPWR VPWR sky130_fd_sc_hd__decap_3
X_6926_ clkload9/A _6926_/D VGND VGND VPWR VPWR _6926_/Q sky130_fd_sc_hd__dfxtp_2
XFILLER_35_570 VGND VGND VPWR VPWR sky130_fd_sc_hd__decap_3
XFILLER_81_197 VGND VGND VPWR VPWR sky130_fd_sc_hd__decap_3
XFILLER_22_242 VGND VGND VPWR VPWR sky130_fd_sc_hd__decap_3
XFILLER_80_18 VGND VGND VPWR VPWR sky130_fd_sc_hd__fill_2
XFILLER_80_29 VGND VGND VPWR VPWR sky130_fd_sc_hd__decap_3
X_6857_ _6923_/CLK _6857_/D VGND VGND VPWR VPWR _6857_/Q sky130_fd_sc_hd__dfxtp_2
XFILLER_22_253 VGND VGND VPWR VPWR sky130_fd_sc_hd__decap_3
X_6788_ _6944_/CLK _6788_/D VGND VGND VPWR VPWR _6788_/Q sky130_fd_sc_hd__dfxtp_2
XFILLER_10_437 VGND VGND VPWR VPWR sky130_fd_sc_hd__fill_1
XFILLER_108_303 VGND VGND VPWR VPWR sky130_fd_sc_hd__decap_3
XFILLER_108_325 VGND VGND VPWR VPWR sky130_fd_sc_hd__decap_3
XFILLER_6_419 VGND VGND VPWR VPWR sky130_fd_sc_hd__fill_1
XTAP_TAPCELL_ROW_79_1242 VGND VPWR sky130_fd_sc_hd__tapvpwrvgnd_1
XFILLER_104_531 VGND VGND VPWR VPWR sky130_fd_sc_hd__fill_1
XFILLER_2_625 VGND VGND VPWR VPWR sky130_fd_sc_hd__decap_3
XFILLER_89_231 VGND VGND VPWR VPWR sky130_fd_sc_hd__fill_2
XFILLER_104_553 VGND VGND VPWR VPWR sky130_fd_sc_hd__decap_3
XFILLER_1_146 VGND VGND VPWR VPWR sky130_fd_sc_hd__decap_3
XFILLER_2_669 VGND VGND VPWR VPWR sky130_fd_sc_hd__decap_3
XFILLER_89_242 VGND VGND VPWR VPWR sky130_fd_sc_hd__decap_3
XFILLER_77_426 VGND VGND VPWR VPWR sky130_fd_sc_hd__decap_3
XFILLER_58_640 VGND VGND VPWR VPWR sky130_fd_sc_hd__decap_3
XFILLER_58_651 VGND VGND VPWR VPWR sky130_fd_sc_hd__decap_3
XFILLER_38_97 VGND VGND VPWR VPWR sky130_fd_sc_hd__decap_3
XFILLER_58_684 VGND VGND VPWR VPWR sky130_fd_sc_hd__decap_3
XFILLER_92_418 VGND VGND VPWR VPWR sky130_fd_sc_hd__fill_2
XFILLER_92_429 VGND VGND VPWR VPWR sky130_fd_sc_hd__decap_3
Xhold1160 _7322_/Q VGND VGND VPWR VPWR _4515_/A0 sky130_fd_sc_hd__dlygate4sd3_1
XFILLER_45_334 VGND VGND VPWR VPWR sky130_fd_sc_hd__fill_2
XFILLER_57_172 VGND VGND VPWR VPWR sky130_fd_sc_hd__fill_2
XFILLER_57_194 VGND VGND VPWR VPWR sky130_fd_sc_hd__decap_3
XFILLER_73_632 VGND VGND VPWR VPWR sky130_fd_sc_hd__decap_3
Xhold1171 _7264_/Q VGND VGND VPWR VPWR _4965_/A0 sky130_fd_sc_hd__dlygate4sd3_1
Xhold1182 _7313_/Q VGND VGND VPWR VPWR _4532_/A0 sky130_fd_sc_hd__dlygate4sd3_1
Xhold1193 _7172_/Q VGND VGND VPWR VPWR _5317_/A0 sky130_fd_sc_hd__dlygate4sd3_1
XFILLER_45_378 VGND VGND VPWR VPWR sky130_fd_sc_hd__decap_3
XFILLER_72_153 VGND VGND VPWR VPWR sky130_fd_sc_hd__decap_3
XFILLER_73_665 VGND VGND VPWR VPWR sky130_fd_sc_hd__decap_3
XFILLER_73_676 VGND VGND VPWR VPWR sky130_fd_sc_hd__decap_3
XFILLER_14_710 VGND VGND VPWR VPWR sky130_fd_sc_hd__decap_3
XFILLER_26_592 VGND VGND VPWR VPWR sky130_fd_sc_hd__decap_3
XFILLER_54_74 VGND VGND VPWR VPWR sky130_fd_sc_hd__fill_2
XFILLER_60_315 VGND VGND VPWR VPWR sky130_fd_sc_hd__fill_1
XFILLER_72_186 VGND VGND VPWR VPWR sky130_fd_sc_hd__decap_3
XFILLER_72_197 VGND VGND VPWR VPWR sky130_fd_sc_hd__decap_3
XFILLER_110_80 VGND VGND VPWR VPWR sky130_fd_sc_hd__decap_3
XFILLER_13_264 VGND VGND VPWR VPWR sky130_fd_sc_hd__fill_2
XFILLER_110_91 VGND VGND VPWR VPWR sky130_fd_sc_hd__decap_3
Xclkload16 _7344_/CLK VGND VGND VPWR VPWR clkload16/Y sky130_fd_sc_hd__bufinv_16
XFILLER_9_279 VGND VGND VPWR VPWR sky130_fd_sc_hd__fill_1
Xclkload27 _7402_/CLK VGND VGND VPWR VPWR clkload27/X sky130_fd_sc_hd__clkbuf_16
XFILLER_5_452 VGND VGND VPWR VPWR sky130_fd_sc_hd__decap_3
XFILLER_107_391 VGND VGND VPWR VPWR sky130_fd_sc_hd__fill_1
XFILLER_5_485 VGND VGND VPWR VPWR sky130_fd_sc_hd__decap_3
XFILLER_68_404 VGND VGND VPWR VPWR sky130_fd_sc_hd__decap_3
XFILLER_79_93 VGND VGND VPWR VPWR sky130_fd_sc_hd__decap_3
XFILLER_96_713 VGND VGND VPWR VPWR sky130_fd_sc_hd__fill_1
XFILLER_110_545 VGND VGND VPWR VPWR sky130_fd_sc_hd__fill_2
XFILLER_1_691 VGND VGND VPWR VPWR sky130_fd_sc_hd__decap_3
XFILLER_68_448 VGND VGND VPWR VPWR sky130_fd_sc_hd__decap_3
X_4070_ _7339_/Q _3945_/S _4428_/B1 _7147_/Q VGND VGND VPWR VPWR _4070_/X sky130_fd_sc_hd__a22o_2
XFILLER_110_589 VGND VGND VPWR VPWR sky130_fd_sc_hd__decap_3
XFILLER_48_150 VGND VGND VPWR VPWR sky130_fd_sc_hd__decap_3
XFILLER_49_662 VGND VGND VPWR VPWR sky130_fd_sc_hd__decap_3
XFILLER_49_673 VGND VGND VPWR VPWR sky130_fd_sc_hd__decap_3
XFILLER_64_610 VGND VGND VPWR VPWR sky130_fd_sc_hd__decap_3
XFILLER_95_267 VGND VGND VPWR VPWR sky130_fd_sc_hd__decap_3
XFILLER_95_92 VGND VGND VPWR VPWR sky130_fd_sc_hd__decap_3
XFILLER_36_312 VGND VGND VPWR VPWR sky130_fd_sc_hd__decap_3
XFILLER_48_172 VGND VGND VPWR VPWR sky130_fd_sc_hd__decap_3
XFILLER_64_643 VGND VGND VPWR VPWR sky130_fd_sc_hd__fill_1
XFILLER_64_654 VGND VGND VPWR VPWR sky130_fd_sc_hd__decap_3
XFILLER_76_492 VGND VGND VPWR VPWR sky130_fd_sc_hd__decap_3
XTAP_TAPCELL_ROW_47_841 VGND VPWR sky130_fd_sc_hd__tapvpwrvgnd_1
XFILLER_24_507 VGND VGND VPWR VPWR sky130_fd_sc_hd__decap_3
XFILLER_63_131 VGND VGND VPWR VPWR sky130_fd_sc_hd__decap_3
XFILLER_64_687 VGND VGND VPWR VPWR sky130_fd_sc_hd__decap_3
XFILLER_17_581 VGND VGND VPWR VPWR sky130_fd_sc_hd__decap_3
XFILLER_63_175 VGND VGND VPWR VPWR sky130_fd_sc_hd__fill_1
XFILLER_63_186 VGND VGND VPWR VPWR sky130_fd_sc_hd__decap_3
XFILLER_91_495 VGND VGND VPWR VPWR sky130_fd_sc_hd__decap_3
X_4972_ _5661_/B VGND VGND VPWR VPWR _4973_/B sky130_fd_sc_hd__inv_2
XFILLER_51_348 VGND VGND VPWR VPWR sky130_fd_sc_hd__fill_2
X_6711_ _7086_/CLK _6711_/D VGND VGND VPWR VPWR _6711_/Q sky130_fd_sc_hd__dfxtp_2
X_3923_ _3629_/A _3922_/X _4791_/A1 VGND VGND VPWR VPWR _3923_/X sky130_fd_sc_hd__a21o_2
XTAP_TAPCELL_ROW_63_1043 VGND VPWR sky130_fd_sc_hd__tapvpwrvgnd_1
XFILLER_20_713 VGND VGND VPWR VPWR sky130_fd_sc_hd__fill_1
X_6642_ _6642_/A VGND VGND VPWR VPWR _6642_/Y sky130_fd_sc_hd__inv_2
X_3854_ _3725_/X _3851_/X _3853_/X _3735_/X VGND VGND VPWR VPWR _3854_/X sky130_fd_sc_hd__a22o_2
XFILLER_32_595 VGND VGND VPWR VPWR sky130_fd_sc_hd__decap_3
XFILLER_118_601 VGND VGND VPWR VPWR sky130_fd_sc_hd__decap_3
XFILLER_118_634 VGND VGND VPWR VPWR sky130_fd_sc_hd__decap_3
X_6573_ _6640_/A VGND VGND VPWR VPWR _6573_/Y sky130_fd_sc_hd__inv_2
X_3785_ _6837_/Q _3840_/A2 _3890_/B1 _6832_/Q _3784_/X VGND VGND VPWR VPWR _3785_/X
+ sky130_fd_sc_hd__a221o_2
XFILLER_118_645 VGND VGND VPWR VPWR sky130_fd_sc_hd__decap_3
XFILLER_8_290 VGND VGND VPWR VPWR sky130_fd_sc_hd__decap_3
XFILLER_117_155 VGND VGND VPWR VPWR sky130_fd_sc_hd__decap_3
XFILLER_117_166 VGND VGND VPWR VPWR sky130_fd_sc_hd__fill_2
XFILLER_118_678 VGND VGND VPWR VPWR sky130_fd_sc_hd__decap_3
XFILLER_105_328 VGND VGND VPWR VPWR sky130_fd_sc_hd__decap_3
X_4406_ _7402_/Q _4437_/B1 _4434_/B1 _7146_/Q _4405_/X VGND VGND VPWR VPWR _4406_/X
+ sky130_fd_sc_hd__a221o_2
X_7125_ _7345_/CLK _7125_/D _6405_/Y VGND VGND VPWR VPWR _7125_/Q sky130_fd_sc_hd__dfrtp_2
Xoutput587 _5655_/D VGND VGND VPWR VPWR alu_result_out[23] sky130_fd_sc_hd__clkdlybuf4s25_1
Xoutput576 _5023_/Y VGND VGND VPWR VPWR alu_result_out[13] sky130_fd_sc_hd__clkdlybuf4s25_1
X_5386_ _5386_/A0 _4899_/X _5390_/S VGND VGND VPWR VPWR _7140_/D sky130_fd_sc_hd__mux2_2
XFILLER_115_36 VGND VGND VPWR VPWR sky130_fd_sc_hd__decap_3
XFILLER_86_212 VGND VGND VPWR VPWR sky130_fd_sc_hd__decap_3
Xoutput598 _3735_/A VGND VGND VPWR VPWR alu_result_out[4] sky130_fd_sc_hd__clkdlybuf4s25_1
X_4337_ _4394_/A _4337_/B _4336_/X VGND VGND VPWR VPWR _4365_/C sky130_fd_sc_hd__or3b_2
XTAP_TAPCELL_ROW_74_1183 VGND VPWR sky130_fd_sc_hd__tapvpwrvgnd_1
XFILLER_115_69 VGND VGND VPWR VPWR sky130_fd_sc_hd__decap_3
XFILLER_86_256 VGND VGND VPWR VPWR sky130_fd_sc_hd__decap_3
X_7056_ _7344_/CLK _7056_/D _6336_/Y VGND VGND VPWR VPWR _7056_/Q sky130_fd_sc_hd__dfstp_2
X_4268_ _7198_/Q _3966_/S _4354_/B1 _7390_/Q VGND VGND VPWR VPWR _4268_/X sky130_fd_sc_hd__a22o_2
XFILLER_101_589 VGND VGND VPWR VPWR sky130_fd_sc_hd__fill_1
XFILLER_39_150 VGND VGND VPWR VPWR sky130_fd_sc_hd__decap_3
XFILLER_27_312 VGND VGND VPWR VPWR sky130_fd_sc_hd__decap_3
XFILLER_39_172 VGND VGND VPWR VPWR sky130_fd_sc_hd__decap_3
XFILLER_54_120 VGND VGND VPWR VPWR sky130_fd_sc_hd__decap_3
XFILLER_55_632 VGND VGND VPWR VPWR sky130_fd_sc_hd__decap_3
X_4199_ _4380_/A _4380_/B VGND VGND VPWR VPWR _4381_/A sky130_fd_sc_hd__nand2_2
XFILLER_54_153 VGND VGND VPWR VPWR sky130_fd_sc_hd__decap_3
XFILLER_55_665 VGND VGND VPWR VPWR sky130_fd_sc_hd__decap_3
XFILLER_55_676 VGND VGND VPWR VPWR sky130_fd_sc_hd__decap_3
XFILLER_42_315 VGND VGND VPWR VPWR sky130_fd_sc_hd__decap_3
XFILLER_54_186 VGND VGND VPWR VPWR sky130_fd_sc_hd__decap_3
XFILLER_54_197 VGND VGND VPWR VPWR sky130_fd_sc_hd__decap_3
XFILLER_70_613 VGND VGND VPWR VPWR sky130_fd_sc_hd__decap_3
XFILLER_82_495 VGND VGND VPWR VPWR sky130_fd_sc_hd__decap_3
XFILLER_91_28 VGND VGND VPWR VPWR sky130_fd_sc_hd__decap_3
XFILLER_24_22 VGND VGND VPWR VPWR sky130_fd_sc_hd__decap_3
XFILLER_42_359 VGND VGND VPWR VPWR sky130_fd_sc_hd__fill_2
XFILLER_70_657 VGND VGND VPWR VPWR sky130_fd_sc_hd__decap_3
X_6909_ clkload7/A _6909_/D VGND VGND VPWR VPWR _6909_/Q sky130_fd_sc_hd__dfxtp_2
XTAP_TAPCELL_ROW_25_568 VGND VPWR sky130_fd_sc_hd__tapvpwrvgnd_1
XFILLER_7_706 VGND VGND VPWR VPWR sky130_fd_sc_hd__decap_3
XFILLER_109_623 VGND VGND VPWR VPWR sky130_fd_sc_hd__decap_3
XFILLER_10_245 VGND VGND VPWR VPWR sky130_fd_sc_hd__decap_3
XFILLER_108_122 VGND VGND VPWR VPWR sky130_fd_sc_hd__decap_3
XFILLER_108_133 VGND VGND VPWR VPWR sky130_fd_sc_hd__decap_3
XFILLER_109_656 VGND VGND VPWR VPWR sky130_fd_sc_hd__decap_3
XFILLER_40_32 VGND VGND VPWR VPWR sky130_fd_sc_hd__decap_3
XFILLER_108_144 VGND VGND VPWR VPWR sky130_fd_sc_hd__decap_3
XFILLER_78_713 VGND VGND VPWR VPWR sky130_fd_sc_hd__fill_1
XFILLER_104_383 VGND VGND VPWR VPWR sky130_fd_sc_hd__decap_3
XFILLER_2_477 VGND VGND VPWR VPWR sky130_fd_sc_hd__decap_3
XFILLER_49_52 VGND VGND VPWR VPWR sky130_fd_sc_hd__decap_3
XFILLER_77_223 VGND VGND VPWR VPWR sky130_fd_sc_hd__fill_1
XFILLER_77_256 VGND VGND VPWR VPWR sky130_fd_sc_hd__decap_3
XFILLER_46_610 VGND VGND VPWR VPWR sky130_fd_sc_hd__decap_3
XFILLER_105_80 VGND VGND VPWR VPWR sky130_fd_sc_hd__decap_3
XFILLER_18_312 VGND VGND VPWR VPWR sky130_fd_sc_hd__decap_3
XFILLER_46_643 VGND VGND VPWR VPWR sky130_fd_sc_hd__fill_1
XFILLER_65_51 VGND VGND VPWR VPWR sky130_fd_sc_hd__decap_3
XFILLER_92_226 VGND VGND VPWR VPWR sky130_fd_sc_hd__decap_3
XFILLER_18_345 VGND VGND VPWR VPWR sky130_fd_sc_hd__decap_3
XFILLER_46_654 VGND VGND VPWR VPWR sky130_fd_sc_hd__decap_3
XFILLER_61_602 VGND VGND VPWR VPWR sky130_fd_sc_hd__decap_3
XFILLER_65_73 VGND VGND VPWR VPWR sky130_fd_sc_hd__fill_1
XFILLER_33_326 VGND VGND VPWR VPWR sky130_fd_sc_hd__decap_3
XFILLER_33_337 VGND VGND VPWR VPWR sky130_fd_sc_hd__decap_3
XFILLER_45_186 VGND VGND VPWR VPWR sky130_fd_sc_hd__decap_3
XFILLER_46_687 VGND VGND VPWR VPWR sky130_fd_sc_hd__decap_3
XFILLER_61_635 VGND VGND VPWR VPWR sky130_fd_sc_hd__decap_3
XTAP_TAPCELL_ROW_44_811 VGND VPWR sky130_fd_sc_hd__tapvpwrvgnd_1
XFILLER_33_348 VGND VGND VPWR VPWR sky130_fd_sc_hd__fill_1
XFILLER_60_134 VGND VGND VPWR VPWR sky130_fd_sc_hd__fill_1
XFILLER_61_668 VGND VGND VPWR VPWR sky130_fd_sc_hd__decap_3
XFILLER_61_679 VGND VGND VPWR VPWR sky130_fd_sc_hd__decap_3
XFILLER_14_573 VGND VGND VPWR VPWR sky130_fd_sc_hd__decap_3
XFILLER_60_167 VGND VGND VPWR VPWR sky130_fd_sc_hd__decap_3
XFILLER_60_189 VGND VGND VPWR VPWR sky130_fd_sc_hd__fill_1
XFILLER_81_72 VGND VGND VPWR VPWR sky130_fd_sc_hd__decap_3
XFILLER_14_595 VGND VGND VPWR VPWR sky130_fd_sc_hd__decap_3
X_3570_ _7157_/Q _3409_/X _4337_/B _3469_/B _3469_/A VGND VGND VPWR VPWR _3570_/X
+ sky130_fd_sc_hd__a2111o_2
XFILLER_115_626 VGND VGND VPWR VPWR sky130_fd_sc_hd__decap_3
XFILLER_114_125 VGND VGND VPWR VPWR sky130_fd_sc_hd__decap_3
XFILLER_115_659 VGND VGND VPWR VPWR sky130_fd_sc_hd__decap_3
X_5240_ _4788_/A _4788_/B _5238_/X _5240_/B2 VGND VGND VPWR VPWR _7210_/D sky130_fd_sc_hd__a22o_2
XFILLER_102_309 VGND VGND VPWR VPWR sky130_fd_sc_hd__decap_3
XFILLER_114_147 VGND VGND VPWR VPWR sky130_fd_sc_hd__decap_3
XFILLER_5_293 VGND VGND VPWR VPWR sky130_fd_sc_hd__fill_2
X_5171_ _5171_/A _5198_/B VGND VGND VPWR VPWR _7242_/D sky130_fd_sc_hd__and2_2
XTAP_TAPCELL_ROW_110_1637 VGND VPWR sky130_fd_sc_hd__tapvpwrvgnd_1
XPHY_EDGE_ROW_18_Right_18 VGND VGND VPWR VPWR sky130_fd_sc_hd__decap_3
XFILLER_68_256 VGND VGND VPWR VPWR sky130_fd_sc_hd__decap_3
XFILLER_96_554 VGND VGND VPWR VPWR sky130_fd_sc_hd__decap_3
X_4122_ _7204_/Q _3947_/S _4269_/B1 _7049_/Q _4121_/X VGND VGND VPWR VPWR _4122_/X
+ sky130_fd_sc_hd__a221o_2
XFILLER_56_407 VGND VGND VPWR VPWR sky130_fd_sc_hd__decap_3
X_4053_ _4054_/A _4456_/A VGND VGND VPWR VPWR _4055_/A sky130_fd_sc_hd__nor2_2
XFILLER_37_632 VGND VGND VPWR VPWR sky130_fd_sc_hd__decap_3
XFILLER_49_492 VGND VGND VPWR VPWR sky130_fd_sc_hd__decap_3
XFILLER_37_665 VGND VGND VPWR VPWR sky130_fd_sc_hd__decap_3
XFILLER_37_676 VGND VGND VPWR VPWR sky130_fd_sc_hd__decap_3
XFILLER_36_164 VGND VGND VPWR VPWR sky130_fd_sc_hd__decap_3
XFILLER_52_613 VGND VGND VPWR VPWR sky130_fd_sc_hd__decap_3
XFILLER_64_495 VGND VGND VPWR VPWR sky130_fd_sc_hd__decap_3
XFILLER_36_197 VGND VGND VPWR VPWR sky130_fd_sc_hd__decap_3
XFILLER_51_134 VGND VGND VPWR VPWR sky130_fd_sc_hd__decap_3
XFILLER_52_657 VGND VGND VPWR VPWR sky130_fd_sc_hd__decap_3
X_4955_ _5114_/A _4639_/A _4200_/A _5033_/B2 VGND VGND VPWR VPWR _4955_/X sky130_fd_sc_hd__a22o_2
XPHY_EDGE_ROW_27_Right_27 VGND VGND VPWR VPWR sky130_fd_sc_hd__decap_3
XFILLER_51_167 VGND VGND VPWR VPWR sky130_fd_sc_hd__fill_1
XFILLER_51_178 VGND VGND VPWR VPWR sky130_fd_sc_hd__decap_3
X_3906_ _6917_/Q _3906_/A2 _5660_/B _6691_/Q VGND VGND VPWR VPWR _3906_/X sky130_fd_sc_hd__a22o_2
XFILLER_32_392 VGND VGND VPWR VPWR sky130_fd_sc_hd__decap_3
XFILLER_60_690 VGND VGND VPWR VPWR sky130_fd_sc_hd__decap_3
X_4886_ _4886_/A _4890_/B _4886_/C VGND VGND VPWR VPWR _4886_/X sky130_fd_sc_hd__or3_2
XTAP_TAPCELL_ROW_22_538 VGND VPWR sky130_fd_sc_hd__tapvpwrvgnd_1
XTAP_TAPCELL_ROW_22_527 VGND VPWR sky130_fd_sc_hd__tapvpwrvgnd_1
XFILLER_20_565 VGND VGND VPWR VPWR sky130_fd_sc_hd__decap_3
X_6625_ _6625_/A VGND VGND VPWR VPWR _6625_/Y sky130_fd_sc_hd__inv_2
X_3837_ _6755_/Q _3887_/A2 _3850_/B1 _6767_/Q VGND VGND VPWR VPWR _3837_/X sky130_fd_sc_hd__a22o_2
XFILLER_118_431 VGND VGND VPWR VPWR sky130_fd_sc_hd__fill_2
XFILLER_20_598 VGND VGND VPWR VPWR sky130_fd_sc_hd__decap_3
X_6556_ _6556_/A VGND VGND VPWR VPWR _6556_/Y sky130_fd_sc_hd__inv_2
X_3768_ _6931_/Q _3926_/A2 _3926_/B1 _6795_/Q VGND VGND VPWR VPWR _3768_/X sky130_fd_sc_hd__a22o_2
XFILLER_106_604 VGND VGND VPWR VPWR sky130_fd_sc_hd__decap_3
XFILLER_118_464 VGND VGND VPWR VPWR sky130_fd_sc_hd__fill_2
XTAP_TAPCELL_ROW_76_1212 VGND VPWR sky130_fd_sc_hd__tapvpwrvgnd_1
XFILLER_106_637 VGND VGND VPWR VPWR sky130_fd_sc_hd__decap_3
XFILLER_106_648 VGND VGND VPWR VPWR sky130_fd_sc_hd__decap_3
XFILLER_10_24 VGND VGND VPWR VPWR sky130_fd_sc_hd__decap_3
X_6487_ _6617_/A VGND VGND VPWR VPWR _6487_/Y sky130_fd_sc_hd__inv_2
X_3699_ _6713_/Q _3760_/B1 _3767_/B1 _6891_/Q VGND VGND VPWR VPWR _3699_/X sky130_fd_sc_hd__a22o_2
XFILLER_105_147 VGND VGND VPWR VPWR sky130_fd_sc_hd__fill_2
XFILLER_105_169 VGND VGND VPWR VPWR sky130_fd_sc_hd__decap_3
XPHY_EDGE_ROW_36_Right_36 VGND VGND VPWR VPWR sky130_fd_sc_hd__decap_3
XFILLER_114_681 VGND VGND VPWR VPWR sky130_fd_sc_hd__decap_3
X_5369_ _5369_/A0 _4752_/X _5379_/S VGND VGND VPWR VPWR _7148_/D sky130_fd_sc_hd__mux2_2
XFILLER_99_381 VGND VGND VPWR VPWR sky130_fd_sc_hd__fill_2
XFILLER_99_370 VGND VGND VPWR VPWR sky130_fd_sc_hd__decap_3
XFILLER_113_180 VGND VGND VPWR VPWR sky130_fd_sc_hd__decap_3
XFILLER_19_11 VGND VGND VPWR VPWR sky130_fd_sc_hd__fill_2
X_7108_ _7333_/CLK _7108_/D _6388_/Y VGND VGND VPWR VPWR _7108_/Q sky130_fd_sc_hd__dfrtp_2
XFILLER_101_364 VGND VGND VPWR VPWR sky130_fd_sc_hd__decap_3
XFILLER_59_278 VGND VGND VPWR VPWR sky130_fd_sc_hd__fill_2
X_7039_ _7390_/CLK _7039_/D _6319_/Y VGND VGND VPWR VPWR _7039_/Q sky130_fd_sc_hd__dfrtp_2
XFILLER_28_610 VGND VGND VPWR VPWR sky130_fd_sc_hd__decap_3
XFILLER_28_643 VGND VGND VPWR VPWR sky130_fd_sc_hd__fill_1
XFILLER_27_131 VGND VGND VPWR VPWR sky130_fd_sc_hd__decap_3
XFILLER_28_654 VGND VGND VPWR VPWR sky130_fd_sc_hd__decap_3
XTAP_TAPCELL_ROW_87_1341 VGND VPWR sky130_fd_sc_hd__tapvpwrvgnd_1
XFILLER_27_175 VGND VGND VPWR VPWR sky130_fd_sc_hd__decap_3
XFILLER_28_687 VGND VGND VPWR VPWR sky130_fd_sc_hd__decap_3
XFILLER_43_635 VGND VGND VPWR VPWR sky130_fd_sc_hd__decap_3
XFILLER_55_484 VGND VGND VPWR VPWR sky130_fd_sc_hd__decap_3
XFILLER_70_421 VGND VGND VPWR VPWR sky130_fd_sc_hd__decap_3
XFILLER_82_270 VGND VGND VPWR VPWR sky130_fd_sc_hd__decap_3
XTAP_TAPCELL_ROW_2_285 VGND VPWR sky130_fd_sc_hd__tapvpwrvgnd_1
XPHY_EDGE_ROW_45_Right_45 VGND VGND VPWR VPWR sky130_fd_sc_hd__decap_3
XFILLER_42_134 VGND VGND VPWR VPWR sky130_fd_sc_hd__decap_3
XFILLER_43_668 VGND VGND VPWR VPWR sky130_fd_sc_hd__decap_3
XFILLER_30_307 VGND VGND VPWR VPWR sky130_fd_sc_hd__fill_1
XFILLER_42_167 VGND VGND VPWR VPWR sky130_fd_sc_hd__fill_1
XFILLER_42_178 VGND VGND VPWR VPWR sky130_fd_sc_hd__decap_3
XFILLER_43_679 VGND VGND VPWR VPWR sky130_fd_sc_hd__decap_3
XFILLER_23_381 VGND VGND VPWR VPWR sky130_fd_sc_hd__decap_3
XFILLER_11_576 VGND VGND VPWR VPWR sky130_fd_sc_hd__decap_3
XFILLER_7_514 VGND VGND VPWR VPWR sky130_fd_sc_hd__decap_3
XFILLER_109_464 VGND VGND VPWR VPWR sky130_fd_sc_hd__fill_2
XTAP_TAPCELL_ROW_98_1481 VGND VPWR sky130_fd_sc_hd__tapvpwrvgnd_1
XFILLER_109_497 VGND VGND VPWR VPWR sky130_fd_sc_hd__decap_3
XPHY_EDGE_ROW_54_Right_54 VGND VGND VPWR VPWR sky130_fd_sc_hd__decap_3
XFILLER_112_607 VGND VGND VPWR VPWR sky130_fd_sc_hd__decap_3
XFILLER_2_241 VGND VGND VPWR VPWR sky130_fd_sc_hd__decap_3
XFILLER_97_329 VGND VGND VPWR VPWR sky130_fd_sc_hd__decap_3
XFILLER_104_180 VGND VGND VPWR VPWR sky130_fd_sc_hd__decap_3
XFILLER_2_285 VGND VGND VPWR VPWR sky130_fd_sc_hd__decap_3
XPHY_EDGE_ROW_29_Left_149 VGND VGND VPWR VPWR sky130_fd_sc_hd__decap_3
XFILLER_78_565 VGND VGND VPWR VPWR sky130_fd_sc_hd__decap_3
XFILLER_78_587 VGND VGND VPWR VPWR sky130_fd_sc_hd__fill_1
XFILLER_19_610 VGND VGND VPWR VPWR sky130_fd_sc_hd__decap_3
XFILLER_19_632 VGND VGND VPWR VPWR sky130_fd_sc_hd__decap_3
XFILLER_76_94 VGND VGND VPWR VPWR sky130_fd_sc_hd__decap_3
XFILLER_19_665 VGND VGND VPWR VPWR sky130_fd_sc_hd__decap_3
XFILLER_19_676 VGND VGND VPWR VPWR sky130_fd_sc_hd__decap_3
XPHY_EDGE_ROW_63_Right_63 VGND VGND VPWR VPWR sky130_fd_sc_hd__decap_3
XFILLER_34_613 VGND VGND VPWR VPWR sky130_fd_sc_hd__decap_3
XFILLER_46_462 VGND VGND VPWR VPWR sky130_fd_sc_hd__decap_3
XFILLER_18_197 VGND VGND VPWR VPWR sky130_fd_sc_hd__decap_3
XFILLER_34_657 VGND VGND VPWR VPWR sky130_fd_sc_hd__decap_3
XFILLER_73_281 VGND VGND VPWR VPWR sky130_fd_sc_hd__decap_3
XFILLER_92_60 VGND VGND VPWR VPWR sky130_fd_sc_hd__decap_3
XFILLER_21_307 VGND VGND VPWR VPWR sky130_fd_sc_hd__decap_3
XFILLER_33_178 VGND VGND VPWR VPWR sky130_fd_sc_hd__decap_3
XPHY_EDGE_ROW_38_Left_158 VGND VGND VPWR VPWR sky130_fd_sc_hd__decap_3
XPHY_EDGE_ROW_1_Left_121 VGND VGND VPWR VPWR sky130_fd_sc_hd__decap_3
XFILLER_42_690 VGND VGND VPWR VPWR sky130_fd_sc_hd__decap_3
X_4740_ _4610_/A _4765_/B _4611_/Y _4762_/A _3548_/X VGND VGND VPWR VPWR _4740_/X
+ sky130_fd_sc_hd__a221o_2
XTAP_TAPCELL_ROW_60_1013 VGND VPWR sky130_fd_sc_hd__tapvpwrvgnd_1
XTAP_TAPCELL_ROW_60_1002 VGND VPWR sky130_fd_sc_hd__tapvpwrvgnd_1
X_4671_ _6991_/Q _4671_/B VGND VGND VPWR VPWR _4982_/B sky130_fd_sc_hd__and2_2
X_7390_ _7390_/CLK _7390_/D _6670_/Y VGND VGND VPWR VPWR _7390_/Q sky130_fd_sc_hd__dfrtp_2
X_6410_ _6636_/A VGND VGND VPWR VPWR _6410_/Y sky130_fd_sc_hd__inv_2
X_3622_ _4852_/A _5057_/A VGND VGND VPWR VPWR _3635_/B sky130_fd_sc_hd__nand2_2
X_6341_ _6533_/A VGND VGND VPWR VPWR _6341_/Y sky130_fd_sc_hd__inv_2
XPHY_EDGE_ROW_72_Right_72 VGND VGND VPWR VPWR sky130_fd_sc_hd__decap_3
XFILLER_115_412 VGND VGND VPWR VPWR sky130_fd_sc_hd__decap_3
X_3553_ _3469_/A _3469_/B _3449_/A _7253_/Q _3365_/A VGND VGND VPWR VPWR _3553_/X
+ sky130_fd_sc_hd__o2111a_2
XFILLER_88_307 VGND VGND VPWR VPWR sky130_fd_sc_hd__fill_1
X_6272_ _6676_/A VGND VGND VPWR VPWR _6272_/Y sky130_fd_sc_hd__inv_2
X_3484_ _4394_/A _4337_/B _3482_/Y _5153_/B VGND VGND VPWR VPWR _3485_/C sky130_fd_sc_hd__o31a_2
XFILLER_102_106 VGND VGND VPWR VPWR sky130_fd_sc_hd__decap_3
XFILLER_103_629 VGND VGND VPWR VPWR sky130_fd_sc_hd__decap_3
XFILLER_88_329 VGND VGND VPWR VPWR sky130_fd_sc_hd__decap_3
X_5223_ _5223_/A _5225_/B VGND VGND VPWR VPWR _7217_/D sky130_fd_sc_hd__and2_2
XPHY_EDGE_ROW_47_Left_167 VGND VGND VPWR VPWR sky130_fd_sc_hd__decap_3
XFILLER_102_139 VGND VGND VPWR VPWR sky130_fd_sc_hd__fill_1
XFILLER_69_532 VGND VGND VPWR VPWR sky130_fd_sc_hd__fill_2
X_5154_ _5152_/Y _5153_/X _5587_/B VGND VGND VPWR VPWR _5154_/Y sky130_fd_sc_hd__a21oi_2
XTAP_TAPCELL_ROW_71_1142 VGND VPWR sky130_fd_sc_hd__tapvpwrvgnd_1
XFILLER_111_662 VGND VGND VPWR VPWR sky130_fd_sc_hd__decap_3
XFILLER_111_673 VGND VGND VPWR VPWR sky130_fd_sc_hd__decap_3
X_4105_ _7205_/Q _3966_/S _4181_/B1 _7397_/Q _4104_/X VGND VGND VPWR VPWR _4105_/X
+ sky130_fd_sc_hd__a221o_2
XFILLER_110_183 VGND VGND VPWR VPWR sky130_fd_sc_hd__decap_3
XFILLER_29_429 VGND VGND VPWR VPWR sky130_fd_sc_hd__decap_3
XFILLER_56_237 VGND VGND VPWR VPWR sky130_fd_sc_hd__fill_2
XFILLER_96_395 VGND VGND VPWR VPWR sky130_fd_sc_hd__decap_3
X_5085_ _5086_/A _5084_/B _5084_/X VGND VGND VPWR VPWR _5085_/X sky130_fd_sc_hd__o21ba_2
XPHY_EDGE_ROW_81_Right_81 VGND VGND VPWR VPWR sky130_fd_sc_hd__decap_3
XFILLER_112_15 VGND VGND VPWR VPWR sky130_fd_sc_hd__decap_3
XFILLER_84_579 VGND VGND VPWR VPWR sky130_fd_sc_hd__decap_3
X_4036_ _7310_/Q _4914_/S _4434_/A2 _7118_/Q _4035_/X VGND VGND VPWR VPWR _4036_/X
+ sky130_fd_sc_hd__a221o_2
XFILLER_112_59 VGND VGND VPWR VPWR sky130_fd_sc_hd__decap_3
XFILLER_25_613 VGND VGND VPWR VPWR sky130_fd_sc_hd__decap_3
XFILLER_25_635 VGND VGND VPWR VPWR sky130_fd_sc_hd__decap_3
XFILLER_25_668 VGND VGND VPWR VPWR sky130_fd_sc_hd__decap_3
XPHY_EDGE_ROW_56_Left_176 VGND VGND VPWR VPWR sky130_fd_sc_hd__decap_3
XFILLER_24_156 VGND VGND VPWR VPWR sky130_fd_sc_hd__decap_3
XFILLER_25_679 VGND VGND VPWR VPWR sky130_fd_sc_hd__decap_3
XFILLER_40_616 VGND VGND VPWR VPWR sky130_fd_sc_hd__decap_3
XFILLER_24_189 VGND VGND VPWR VPWR sky130_fd_sc_hd__decap_3
XFILLER_52_498 VGND VGND VPWR VPWR sky130_fd_sc_hd__decap_3
X_4938_ _4938_/A _4938_/B VGND VGND VPWR VPWR _4938_/Y sky130_fd_sc_hd__nor2_2
XTAP_TAPCELL_ROW_82_1282 VGND VPWR sky130_fd_sc_hd__tapvpwrvgnd_1
XTAP_TAPCELL_ROW_35_696 VGND VPWR sky130_fd_sc_hd__tapvpwrvgnd_1
X_4869_ _6999_/Q _4858_/B _4777_/A VGND VGND VPWR VPWR _4870_/B sky130_fd_sc_hd__o21ai_2
X_6608_ _6608_/A VGND VGND VPWR VPWR _6608_/Y sky130_fd_sc_hd__inv_2
XPHY_EDGE_ROW_90_Right_90 VGND VGND VPWR VPWR sky130_fd_sc_hd__decap_3
XFILLER_115_6 VGND VGND VPWR VPWR sky130_fd_sc_hd__decap_3
XFILLER_106_401 VGND VGND VPWR VPWR sky130_fd_sc_hd__decap_3
XFILLER_4_539 VGND VGND VPWR VPWR sky130_fd_sc_hd__decap_3
X_6539_ _6637_/A VGND VGND VPWR VPWR _6539_/Y sky130_fd_sc_hd__inv_2
XPHY_EDGE_ROW_65_Left_185 VGND VGND VPWR VPWR sky130_fd_sc_hd__decap_3
XFILLER_0_701 VGND VGND VPWR VPWR sky130_fd_sc_hd__decap_3
XFILLER_102_640 VGND VGND VPWR VPWR sky130_fd_sc_hd__decap_3
XTAP_TAPCELL_ROW_7_344 VGND VPWR sky130_fd_sc_hd__tapvpwrvgnd_1
XFILLER_102_651 VGND VGND VPWR VPWR sky130_fd_sc_hd__decap_3
XFILLER_75_513 VGND VGND VPWR VPWR sky130_fd_sc_hd__decap_3
XFILLER_87_340 VGND VGND VPWR VPWR sky130_fd_sc_hd__decap_3
XFILLER_101_161 VGND VGND VPWR VPWR sky130_fd_sc_hd__decap_3
XFILLER_101_172 VGND VGND VPWR VPWR sky130_fd_sc_hd__decap_3
XFILLER_102_684 VGND VGND VPWR VPWR sky130_fd_sc_hd__decap_3
XFILLER_47_237 VGND VGND VPWR VPWR sky130_fd_sc_hd__decap_3
XFILLER_16_613 VGND VGND VPWR VPWR sky130_fd_sc_hd__decap_3
XFILLER_55_270 VGND VGND VPWR VPWR sky130_fd_sc_hd__decap_3
XPHY_EDGE_ROW_74_Left_194 VGND VGND VPWR VPWR sky130_fd_sc_hd__decap_3
XFILLER_16_657 VGND VGND VPWR VPWR sky130_fd_sc_hd__decap_3
XFILLER_28_495 VGND VGND VPWR VPWR sky130_fd_sc_hd__fill_2
XFILLER_55_281 VGND VGND VPWR VPWR sky130_fd_sc_hd__decap_3
XFILLER_43_476 VGND VGND VPWR VPWR sky130_fd_sc_hd__decap_3
XFILLER_70_251 VGND VGND VPWR VPWR sky130_fd_sc_hd__fill_1
XFILLER_24_690 VGND VGND VPWR VPWR sky130_fd_sc_hd__decap_3
XFILLER_31_638 VGND VGND VPWR VPWR sky130_fd_sc_hd__decap_3
XFILLER_70_273 VGND VGND VPWR VPWR sky130_fd_sc_hd__fill_1
XFILLER_62_85 VGND VGND VPWR VPWR sky130_fd_sc_hd__fill_1
XFILLER_11_351 VGND VGND VPWR VPWR sky130_fd_sc_hd__fill_1
XFILLER_7_311 VGND VGND VPWR VPWR sky130_fd_sc_hd__decap_3
XFILLER_109_261 VGND VGND VPWR VPWR sky130_fd_sc_hd__fill_2
XFILLER_109_272 VGND VGND VPWR VPWR sky130_fd_sc_hd__decap_3
XFILLER_3_550 VGND VGND VPWR VPWR sky130_fd_sc_hd__decap_3
XFILLER_3_561 VGND VGND VPWR VPWR sky130_fd_sc_hd__decap_3
XFILLER_98_627 VGND VGND VPWR VPWR sky130_fd_sc_hd__decap_3
XFILLER_3_594 VGND VGND VPWR VPWR sky130_fd_sc_hd__decap_3
XFILLER_87_60 VGND VGND VPWR VPWR sky130_fd_sc_hd__fill_2
XFILLER_97_126 VGND VGND VPWR VPWR sky130_fd_sc_hd__fill_2
XFILLER_97_159 VGND VGND VPWR VPWR sky130_fd_sc_hd__decap_3
XFILLER_78_384 VGND VGND VPWR VPWR sky130_fd_sc_hd__decap_3
XFILLER_38_259 VGND VGND VPWR VPWR sky130_fd_sc_hd__decap_3
XFILLER_93_343 VGND VGND VPWR VPWR sky130_fd_sc_hd__decap_3
XFILLER_19_473 VGND VGND VPWR VPWR sky130_fd_sc_hd__decap_3
XFILLER_34_421 VGND VGND VPWR VPWR sky130_fd_sc_hd__decap_3
XFILLER_34_432 VGND VGND VPWR VPWR sky130_fd_sc_hd__fill_1
XFILLER_46_292 VGND VGND VPWR VPWR sky130_fd_sc_hd__decap_3
XFILLER_81_549 VGND VGND VPWR VPWR sky130_fd_sc_hd__decap_3
X_6890_ _6941_/CLK _6890_/D VGND VGND VPWR VPWR _6890_/Q sky130_fd_sc_hd__dfxtp_2
XTAP_TAPCELL_ROW_52_909 VGND VPWR sky130_fd_sc_hd__tapvpwrvgnd_1
XFILLER_22_616 VGND VGND VPWR VPWR sky130_fd_sc_hd__decap_3
XTAP_TAPCELL_ROW_105_1569 VGND VPWR sky130_fd_sc_hd__tapvpwrvgnd_1
X_4723_ _3536_/B _4720_/A _4721_/Y _4970_/A1 VGND VGND VPWR VPWR _4723_/X sky130_fd_sc_hd__a22o_2
XTAP_TAPCELL_ROW_32_655 VGND VPWR sky130_fd_sc_hd__tapvpwrvgnd_1
XFILLER_30_660 VGND VGND VPWR VPWR sky130_fd_sc_hd__decap_3
XFILLER_30_693 VGND VGND VPWR VPWR sky130_fd_sc_hd__decap_3
X_4654_ _4646_/Y _4647_/X _4653_/Y _4788_/B VGND VGND VPWR VPWR _4762_/A sky130_fd_sc_hd__a211o_2
XFILLER_116_710 VGND VGND VPWR VPWR sky130_fd_sc_hd__decap_3
X_7373_ _7373_/CLK _7373_/D _6653_/Y VGND VGND VPWR VPWR _7373_/Q sky130_fd_sc_hd__dfrtp_2
Xhold801 _6802_/Q VGND VGND VPWR VPWR _6802_/D sky130_fd_sc_hd__dlygate4sd3_1
Xhold812 _6958_/Q VGND VGND VPWR VPWR _6958_/D sky130_fd_sc_hd__dlygate4sd3_1
X_4585_ _4585_/A _4593_/B VGND VGND VPWR VPWR _7288_/D sky130_fd_sc_hd__and2_2
X_3605_ _3621_/A _3621_/B VGND VGND VPWR VPWR _3605_/Y sky130_fd_sc_hd__nor2b_2
Xhold823 _6948_/Q VGND VGND VPWR VPWR _6948_/D sky130_fd_sc_hd__dlygate4sd3_1
Xhold834 _6800_/Q VGND VGND VPWR VPWR _6800_/D sky130_fd_sc_hd__dlygate4sd3_1
Xhold845 _6947_/Q VGND VGND VPWR VPWR _6947_/D sky130_fd_sc_hd__dlygate4sd3_1
X_6324_ _6676_/A VGND VGND VPWR VPWR _6324_/Y sky130_fd_sc_hd__inv_2
X_3536_ _4614_/A _3536_/B VGND VGND VPWR VPWR _3536_/Y sky130_fd_sc_hd__nand2_2
XFILLER_107_15 VGND VGND VPWR VPWR sky130_fd_sc_hd__decap_3
XFILLER_89_638 VGND VGND VPWR VPWR sky130_fd_sc_hd__decap_3
Xhold856 _6962_/Q VGND VGND VPWR VPWR _6962_/D sky130_fd_sc_hd__dlygate4sd3_1
Xhold867 _6867_/Q VGND VGND VPWR VPWR _6867_/D sky130_fd_sc_hd__dlygate4sd3_1
Xhold878 _6749_/Q VGND VGND VPWR VPWR _6749_/D sky130_fd_sc_hd__dlygate4sd3_1
Xhold889 _6899_/Q VGND VGND VPWR VPWR _6899_/D sky130_fd_sc_hd__dlygate4sd3_1
XFILLER_103_426 VGND VGND VPWR VPWR sky130_fd_sc_hd__decap_3
XFILLER_88_126 VGND VGND VPWR VPWR sky130_fd_sc_hd__decap_3
X_3467_ _7121_/Q _3407_/X _4352_/B1 _7153_/Q _3466_/X VGND VGND VPWR VPWR _3467_/X
+ sky130_fd_sc_hd__a221o_2
XFILLER_69_340 VGND VGND VPWR VPWR sky130_fd_sc_hd__fill_1
XFILLER_88_159 VGND VGND VPWR VPWR sky130_fd_sc_hd__decap_3
XFILLER_97_671 VGND VGND VPWR VPWR sky130_fd_sc_hd__fill_1
X_3398_ _4534_/S VGND VGND VPWR VPWR _3398_/Y sky130_fd_sc_hd__inv_2
XTAP_TAPCELL_ROW_4_314 VGND VPWR sky130_fd_sc_hd__tapvpwrvgnd_1
XTAP_TAPCELL_ROW_4_303 VGND VPWR sky130_fd_sc_hd__tapvpwrvgnd_1
XFILLER_69_373 VGND VGND VPWR VPWR sky130_fd_sc_hd__decap_3
XFILLER_97_682 VGND VGND VPWR VPWR sky130_fd_sc_hd__decap_3
XFILLER_111_492 VGND VGND VPWR VPWR sky130_fd_sc_hd__fill_1
XFILLER_84_332 VGND VGND VPWR VPWR sky130_fd_sc_hd__decap_3
XFILLER_96_192 VGND VGND VPWR VPWR sky130_fd_sc_hd__decap_3
X_5068_ _6985_/Q _6986_/Q _5068_/C VGND VGND VPWR VPWR _5069_/B sky130_fd_sc_hd__and3_2
XFILLER_44_218 VGND VGND VPWR VPWR sky130_fd_sc_hd__decap_3
XFILLER_84_365 VGND VGND VPWR VPWR sky130_fd_sc_hd__decap_3
X_4019_ _7278_/Q _4131_/A2 _4430_/A2 _7246_/Q _4018_/X VGND VGND VPWR VPWR _4019_/X
+ sky130_fd_sc_hd__a221o_2
XFILLER_25_410 VGND VGND VPWR VPWR sky130_fd_sc_hd__decap_3
XFILLER_37_292 VGND VGND VPWR VPWR sky130_fd_sc_hd__decap_3
XTAP_TAPCELL_ROW_84_1311 VGND VPWR sky130_fd_sc_hd__tapvpwrvgnd_1
XPHY_EDGE_ROW_0_Right_0 VGND VGND VPWR VPWR sky130_fd_sc_hd__decap_3
XFILLER_13_638 VGND VGND VPWR VPWR sky130_fd_sc_hd__decap_3
XFILLER_25_487 VGND VGND VPWR VPWR sky130_fd_sc_hd__decap_3
XFILLER_52_273 VGND VGND VPWR VPWR sky130_fd_sc_hd__fill_1
XFILLER_9_609 VGND VGND VPWR VPWR sky130_fd_sc_hd__decap_3
XFILLER_21_671 VGND VGND VPWR VPWR sky130_fd_sc_hd__fill_1
XFILLER_21_682 VGND VGND VPWR VPWR sky130_fd_sc_hd__decap_3
XFILLER_113_3 VGND VGND VPWR VPWR sky130_fd_sc_hd__decap_3
XFILLER_119_570 VGND VGND VPWR VPWR sky130_fd_sc_hd__decap_3
XFILLER_4_303 VGND VGND VPWR VPWR sky130_fd_sc_hd__decap_3
XTAP_TAPCELL_ROW_95_1451 VGND VPWR sky130_fd_sc_hd__tapvpwrvgnd_1
XTAP_TAPCELL_ROW_95_1440 VGND VPWR sky130_fd_sc_hd__tapvpwrvgnd_1
XFILLER_106_253 VGND VGND VPWR VPWR sky130_fd_sc_hd__decap_3
XFILLER_0_531 VGND VGND VPWR VPWR sky130_fd_sc_hd__fill_1
XFILLER_79_137 VGND VGND VPWR VPWR sky130_fd_sc_hd__decap_3
XFILLER_79_159 VGND VGND VPWR VPWR sky130_fd_sc_hd__decap_3
XFILLER_88_660 VGND VGND VPWR VPWR sky130_fd_sc_hd__decap_3
XFILLER_0_597 VGND VGND VPWR VPWR sky130_fd_sc_hd__decap_3
XFILLER_102_470 VGND VGND VPWR VPWR sky130_fd_sc_hd__decap_3
XFILLER_57_41 VGND VGND VPWR VPWR sky130_fd_sc_hd__fill_2
XFILLER_87_181 VGND VGND VPWR VPWR sky130_fd_sc_hd__decap_3
XFILLER_88_693 VGND VGND VPWR VPWR sky130_fd_sc_hd__decap_3
XFILLER_57_63 VGND VGND VPWR VPWR sky130_fd_sc_hd__decap_3
XFILLER_75_343 VGND VGND VPWR VPWR sky130_fd_sc_hd__fill_2
XPHY_EDGE_ROW_82_Left_202 VGND VGND VPWR VPWR sky130_fd_sc_hd__decap_3
XFILLER_63_505 VGND VGND VPWR VPWR sky130_fd_sc_hd__decap_3
XFILLER_63_538 VGND VGND VPWR VPWR sky130_fd_sc_hd__fill_1
XFILLER_16_421 VGND VGND VPWR VPWR sky130_fd_sc_hd__decap_3
XFILLER_90_357 VGND VGND VPWR VPWR sky130_fd_sc_hd__decap_3
Xplace505 _6982_/Q VGND VGND VPWR VPWR _3340_/A sky130_fd_sc_hd__buf_2
Xplace516 _6653_/A VGND VGND VPWR VPWR _6557_/A sky130_fd_sc_hd__buf_2
Xplace527 _6554_/A VGND VGND VPWR VPWR _6649_/A sky130_fd_sc_hd__buf_2
Xplace538 _6667_/A VGND VGND VPWR VPWR _6671_/A sky130_fd_sc_hd__buf_2
XFILLER_16_454 VGND VGND VPWR VPWR sky130_fd_sc_hd__decap_3
XFILLER_90_368 VGND VGND VPWR VPWR sky130_fd_sc_hd__decap_3
Xplace549 _6610_/A VGND VGND VPWR VPWR _6584_/A sky130_fd_sc_hd__buf_2
XFILLER_16_498 VGND VGND VPWR VPWR sky130_fd_sc_hd__decap_3
XFILLER_43_262 VGND VGND VPWR VPWR sky130_fd_sc_hd__decap_3
XFILLER_43_284 VGND VGND VPWR VPWR sky130_fd_sc_hd__fill_1
XFILLER_71_571 VGND VGND VPWR VPWR sky130_fd_sc_hd__decap_3
XFILLER_12_660 VGND VGND VPWR VPWR sky130_fd_sc_hd__decap_3
XFILLER_8_631 VGND VGND VPWR VPWR sky130_fd_sc_hd__decap_3
XPHY_EDGE_ROW_91_Left_211 VGND VGND VPWR VPWR sky130_fd_sc_hd__decap_3
XFILLER_12_693 VGND VGND VPWR VPWR sky130_fd_sc_hd__decap_3
XFILLER_7_141 VGND VGND VPWR VPWR sky130_fd_sc_hd__decap_3
XFILLER_8_675 VGND VGND VPWR VPWR sky130_fd_sc_hd__decap_3
X_4370_ _5100_/B _4361_/X _4362_/X _4369_/Y VGND VGND VPWR VPWR _5032_/B sky130_fd_sc_hd__a211o_2
X_3321_ _6981_/Q _3327_/B VGND VGND VPWR VPWR _5294_/A sky130_fd_sc_hd__or2_4
XFILLER_112_245 VGND VGND VPWR VPWR sky130_fd_sc_hd__decap_3
XFILLER_112_256 VGND VGND VPWR VPWR sky130_fd_sc_hd__decap_3
XFILLER_66_321 VGND VGND VPWR VPWR sky130_fd_sc_hd__fill_2
XFILLER_79_671 VGND VGND VPWR VPWR sky130_fd_sc_hd__fill_1
XFILLER_79_682 VGND VGND VPWR VPWR sky130_fd_sc_hd__decap_3
XFILLER_78_181 VGND VGND VPWR VPWR sky130_fd_sc_hd__decap_3
XFILLER_93_140 VGND VGND VPWR VPWR sky130_fd_sc_hd__decap_3
XFILLER_94_663 VGND VGND VPWR VPWR sky130_fd_sc_hd__decap_3
XFILLER_26_218 VGND VGND VPWR VPWR sky130_fd_sc_hd__decap_3
XFILLER_54_516 VGND VGND VPWR VPWR sky130_fd_sc_hd__decap_3
XFILLER_81_313 VGND VGND VPWR VPWR sky130_fd_sc_hd__decap_3
XFILLER_93_162 VGND VGND VPWR VPWR sky130_fd_sc_hd__decap_3
XFILLER_94_696 VGND VGND VPWR VPWR sky130_fd_sc_hd__decap_3
XTAP_TAPCELL_ROW_37_725 VGND VPWR sky130_fd_sc_hd__tapvpwrvgnd_1
XFILLER_19_281 VGND VGND VPWR VPWR sky130_fd_sc_hd__decap_3
XFILLER_93_184 VGND VGND VPWR VPWR sky130_fd_sc_hd__decap_3
X_6942_ _6942_/CLK _6942_/D VGND VGND VPWR VPWR _6942_/Q sky130_fd_sc_hd__dfxtp_2
XFILLER_62_560 VGND VGND VPWR VPWR sky130_fd_sc_hd__decap_3
XFILLER_81_368 VGND VGND VPWR VPWR sky130_fd_sc_hd__decap_3
X_6873_ _6922_/CLK _6873_/D VGND VGND VPWR VPWR _6873_/Q sky130_fd_sc_hd__dfxtp_2
XFILLER_22_424 VGND VGND VPWR VPWR sky130_fd_sc_hd__decap_3
XFILLER_34_262 VGND VGND VPWR VPWR sky130_fd_sc_hd__decap_3
XTAP_TAPCELL_ROW_66_1085 VGND VPWR sky130_fd_sc_hd__tapvpwrvgnd_1
XTAP_TAPCELL_ROW_17_471 VGND VPWR sky130_fd_sc_hd__tapvpwrvgnd_1
XFILLER_10_619 VGND VGND VPWR VPWR sky130_fd_sc_hd__decap_3
X_5686_ _7349_/Q _5686_/A1 _5708_/S VGND VGND VPWR VPWR _6693_/D sky130_fd_sc_hd__mux2_2
X_4706_ _6997_/Q _4931_/A VGND VGND VPWR VPWR _4912_/A sky130_fd_sc_hd__and2_2
XTAP_TAPCELL_ROW_118_1727 VGND VPWR sky130_fd_sc_hd__tapvpwrvgnd_1
XFILLER_108_529 VGND VGND VPWR VPWR sky130_fd_sc_hd__decap_3
X_4637_ _4380_/B _4637_/B _4637_/C VGND VGND VPWR VPWR _4950_/B sky130_fd_sc_hd__and3b_2
XTAP_TAPCELL_ROW_118_1738 VGND VPWR sky130_fd_sc_hd__tapvpwrvgnd_1
XFILLER_118_25 VGND VGND VPWR VPWR sky130_fd_sc_hd__decap_3
XFILLER_118_47 VGND VGND VPWR VPWR sky130_fd_sc_hd__decap_3
XFILLER_104_713 VGND VGND VPWR VPWR sky130_fd_sc_hd__fill_1
XFILLER_116_562 VGND VGND VPWR VPWR sky130_fd_sc_hd__decap_3
XFILLER_116_573 VGND VGND VPWR VPWR sky130_fd_sc_hd__decap_3
XFILLER_78_29 VGND VGND VPWR VPWR sky130_fd_sc_hd__decap_3
X_7356_ _7360_/CLK _7356_/D _6636_/Y VGND VGND VPWR VPWR _7356_/Q sky130_fd_sc_hd__dfrtp_2
XFILLER_103_223 VGND VGND VPWR VPWR sky130_fd_sc_hd__fill_1
XFILLER_116_595 VGND VGND VPWR VPWR sky130_fd_sc_hd__decap_3
XFILLER_89_424 VGND VGND VPWR VPWR sky130_fd_sc_hd__decap_3
X_7287_ _7355_/CLK _7287_/D _6567_/Y VGND VGND VPWR VPWR _7287_/Q sky130_fd_sc_hd__dfrtp_2
Xhold686 _6808_/Q VGND VGND VPWR VPWR _6808_/D sky130_fd_sc_hd__dlygate4sd3_1
Xhold697 _6795_/Q VGND VGND VPWR VPWR _6795_/D sky130_fd_sc_hd__dlygate4sd3_1
X_6307_ _6483_/A VGND VGND VPWR VPWR _6307_/Y sky130_fd_sc_hd__inv_2
X_4499_ _7330_/Q _7298_/Q _4517_/S VGND VGND VPWR VPWR _7330_/D sky130_fd_sc_hd__mux2_2
X_3519_ _5129_/B _3519_/B VGND VGND VPWR VPWR _3519_/Y sky130_fd_sc_hd__nor2_2
XFILLER_103_267 VGND VGND VPWR VPWR sky130_fd_sc_hd__decap_3
XTAP_TAPCELL_ROW_90_1381 VGND VPWR sky130_fd_sc_hd__tapvpwrvgnd_1
XFILLER_69_181 VGND VGND VPWR VPWR sky130_fd_sc_hd__decap_3
XFILLER_69_192 VGND VGND VPWR VPWR sky130_fd_sc_hd__decap_3
XFILLER_85_641 VGND VGND VPWR VPWR sky130_fd_sc_hd__decap_3
Xhold1320 _7216_/Q VGND VGND VPWR VPWR _5225_/A sky130_fd_sc_hd__dlygate4sd3_1
XFILLER_45_505 VGND VGND VPWR VPWR sky130_fd_sc_hd__decap_3
XFILLER_45_527 VGND VGND VPWR VPWR sky130_fd_sc_hd__decap_3
XFILLER_72_302 VGND VGND VPWR VPWR sky130_fd_sc_hd__decap_3
XFILLER_85_685 VGND VGND VPWR VPWR sky130_fd_sc_hd__decap_3
XFILLER_27_88 VGND VGND VPWR VPWR sky130_fd_sc_hd__decap_3
XFILLER_41_700 VGND VGND VPWR VPWR sky130_fd_sc_hd__decap_3
XFILLER_72_368 VGND VGND VPWR VPWR sky130_fd_sc_hd__decap_3
XFILLER_13_402 VGND VGND VPWR VPWR sky130_fd_sc_hd__fill_1
XFILLER_25_284 VGND VGND VPWR VPWR sky130_fd_sc_hd__decap_3
XFILLER_13_435 VGND VGND VPWR VPWR sky130_fd_sc_hd__decap_3
XFILLER_40_221 VGND VGND VPWR VPWR sky130_fd_sc_hd__decap_3
XFILLER_43_54 VGND VGND VPWR VPWR sky130_fd_sc_hd__fill_2
XFILLER_9_417 VGND VGND VPWR VPWR sky130_fd_sc_hd__decap_3
XFILLER_40_265 VGND VGND VPWR VPWR sky130_fd_sc_hd__decap_3
XFILLER_40_298 VGND VGND VPWR VPWR sky130_fd_sc_hd__fill_1
Xclkbuf_leaf_20_clk clkload2/A VGND VGND VPWR VPWR _7374_/CLK sky130_fd_sc_hd__clkbuf_16
XFILLER_5_612 VGND VGND VPWR VPWR sky130_fd_sc_hd__decap_3
XFILLER_5_623 VGND VGND VPWR VPWR sky130_fd_sc_hd__decap_3
XFILLER_5_656 VGND VGND VPWR VPWR sky130_fd_sc_hd__decap_3
XFILLER_107_551 VGND VGND VPWR VPWR sky130_fd_sc_hd__decap_3
XFILLER_107_595 VGND VGND VPWR VPWR sky130_fd_sc_hd__decap_3
XFILLER_95_449 VGND VGND VPWR VPWR sky130_fd_sc_hd__decap_3
XFILLER_76_630 VGND VGND VPWR VPWR sky130_fd_sc_hd__decap_3
XFILLER_36_505 VGND VGND VPWR VPWR sky130_fd_sc_hd__decap_3
XFILLER_48_365 VGND VGND VPWR VPWR sky130_fd_sc_hd__decap_3
XFILLER_63_313 VGND VGND VPWR VPWR sky130_fd_sc_hd__decap_3
XFILLER_75_162 VGND VGND VPWR VPWR sky130_fd_sc_hd__decap_3
XFILLER_76_663 VGND VGND VPWR VPWR sky130_fd_sc_hd__decap_3
XFILLER_76_696 VGND VGND VPWR VPWR sky130_fd_sc_hd__decap_3
XFILLER_91_600 VGND VGND VPWR VPWR sky130_fd_sc_hd__fill_1
XFILLER_75_184 VGND VGND VPWR VPWR sky130_fd_sc_hd__decap_3
XFILLER_90_121 VGND VGND VPWR VPWR sky130_fd_sc_hd__decap_3
XFILLER_91_644 VGND VGND VPWR VPWR sky130_fd_sc_hd__decap_3
XFILLER_51_508 VGND VGND VPWR VPWR sky130_fd_sc_hd__decap_3
XFILLER_84_94 VGND VGND VPWR VPWR sky130_fd_sc_hd__decap_3
XFILLER_91_688 VGND VGND VPWR VPWR sky130_fd_sc_hd__decap_3
Xplace346 _3886_/B1 VGND VGND VPWR VPWR _3853_/A2 sky130_fd_sc_hd__buf_2
Xplace335 _3851_/A2 VGND VGND VPWR VPWR _3906_/A2 sky130_fd_sc_hd__buf_2
Xplace324 _3912_/B1 VGND VGND VPWR VPWR _3925_/B1 sky130_fd_sc_hd__buf_2
XFILLER_16_262 VGND VGND VPWR VPWR sky130_fd_sc_hd__decap_3
Xplace379 _4205_/A VGND VGND VPWR VPWR _4432_/B1 sky130_fd_sc_hd__buf_2
Xplace368 _4593_/B VGND VGND VPWR VPWR _4577_/B sky130_fd_sc_hd__buf_2
Xplace357 _4619_/A VGND VGND VPWR VPWR _5086_/A sky130_fd_sc_hd__buf_2
XTAP_TAPCELL_ROW_102_1528 VGND VPWR sky130_fd_sc_hd__tapvpwrvgnd_1
XFILLER_16_295 VGND VGND VPWR VPWR sky130_fd_sc_hd__decap_3
XFILLER_31_243 VGND VGND VPWR VPWR sky130_fd_sc_hd__decap_3
X_3870_ _6760_/Q _3910_/B1 _3913_/B1 _6754_/Q _3869_/X VGND VGND VPWR VPWR _3870_/X
+ sky130_fd_sc_hd__a221o_2
XTAP_TAPCELL_ROW_14_430 VGND VPWR sky130_fd_sc_hd__tapvpwrvgnd_1
XTAP_TAPCELL_ROW_102_1539 VGND VPWR sky130_fd_sc_hd__tapvpwrvgnd_1
XTAP_TAPCELL_ROW_42_783 VGND VPWR sky130_fd_sc_hd__tapvpwrvgnd_1
XFILLER_76_3 VGND VGND VPWR VPWR sky130_fd_sc_hd__decap_3
Xclkbuf_leaf_11_clk clkload1/A VGND VGND VPWR VPWR _6941_/CLK sky130_fd_sc_hd__clkbuf_16
XFILLER_8_472 VGND VGND VPWR VPWR sky130_fd_sc_hd__decap_3
XFILLER_8_483 VGND VGND VPWR VPWR sky130_fd_sc_hd__decap_3
X_7210_ _7402_/CLK _7210_/D _6490_/Y VGND VGND VPWR VPWR _7210_/Q sky130_fd_sc_hd__dfrtp_2
X_4422_ _7272_/Q _4422_/A2 _4419_/X _4421_/X VGND VGND VPWR VPWR _4422_/X sky130_fd_sc_hd__a211o_2
XFILLER_99_700 VGND VGND VPWR VPWR sky130_fd_sc_hd__decap_3
XFILLER_98_210 VGND VGND VPWR VPWR sky130_fd_sc_hd__decap_3
X_7141_ _7370_/CLK _7141_/D _6421_/Y VGND VGND VPWR VPWR _7141_/Q sky130_fd_sc_hd__dfrtp_2
X_4353_ _7225_/Q _4353_/A2 _3966_/S _7193_/Q VGND VGND VPWR VPWR _4355_/A sky130_fd_sc_hd__a22o_2
XFILLER_113_554 VGND VGND VPWR VPWR sky130_fd_sc_hd__decap_3
X_7072_ _7396_/CLK _7072_/D _6352_/Y VGND VGND VPWR VPWR _7072_/Q sky130_fd_sc_hd__dfrtp_2
X_4284_ _7222_/Q _4307_/A2 _3987_/S _7190_/Q VGND VGND VPWR VPWR _4286_/A sky130_fd_sc_hd__a22o_2
X_3304_ _3340_/A _3327_/B VGND VGND VPWR VPWR _4696_/B sky130_fd_sc_hd__nand2_2
XTAP_TAPCELL_ROW_113_1668 VGND VPWR sky130_fd_sc_hd__tapvpwrvgnd_1
XFILLER_113_576 VGND VGND VPWR VPWR sky130_fd_sc_hd__decap_3
XFILLER_39_310 VGND VGND VPWR VPWR sky130_fd_sc_hd__decap_3
XFILLER_86_427 VGND VGND VPWR VPWR sky130_fd_sc_hd__decap_3
XFILLER_100_259 VGND VGND VPWR VPWR sky130_fd_sc_hd__decap_3
XFILLER_104_16 VGND VGND VPWR VPWR sky130_fd_sc_hd__decap_3
XFILLER_67_641 VGND VGND VPWR VPWR sky130_fd_sc_hd__decap_3
XFILLER_104_38 VGND VGND VPWR VPWR sky130_fd_sc_hd__decap_3
XFILLER_27_505 VGND VGND VPWR VPWR sky130_fd_sc_hd__decap_3
XFILLER_39_354 VGND VGND VPWR VPWR sky130_fd_sc_hd__decap_3
XFILLER_39_376 VGND VGND VPWR VPWR sky130_fd_sc_hd__decap_3
XFILLER_67_685 VGND VGND VPWR VPWR sky130_fd_sc_hd__decap_3
XTAP_TAPCELL_ROW_68_1114 VGND VPWR sky130_fd_sc_hd__tapvpwrvgnd_1
XTAP_TAPCELL_ROW_68_1103 VGND VPWR sky130_fd_sc_hd__tapvpwrvgnd_1
XFILLER_82_622 VGND VGND VPWR VPWR sky130_fd_sc_hd__decap_3
XFILLER_23_700 VGND VGND VPWR VPWR sky130_fd_sc_hd__decap_3
XFILLER_42_508 VGND VGND VPWR VPWR sky130_fd_sc_hd__decap_3
XFILLER_54_357 VGND VGND VPWR VPWR sky130_fd_sc_hd__decap_3
XFILLER_54_368 VGND VGND VPWR VPWR sky130_fd_sc_hd__fill_1
XFILLER_81_143 VGND VGND VPWR VPWR sky130_fd_sc_hd__decap_3
XFILLER_82_666 VGND VGND VPWR VPWR sky130_fd_sc_hd__decap_3
X_6925_ _6983_/CLK _6925_/D VGND VGND VPWR VPWR _6925_/Q sky130_fd_sc_hd__dfxtp_2
XFILLER_35_582 VGND VGND VPWR VPWR sky130_fd_sc_hd__decap_3
XFILLER_82_699 VGND VGND VPWR VPWR sky130_fd_sc_hd__fill_1
X_6856_ _6942_/CLK _6856_/D VGND VGND VPWR VPWR _6856_/Q sky130_fd_sc_hd__dfxtp_2
XFILLER_10_405 VGND VGND VPWR VPWR sky130_fd_sc_hd__fill_2
XFILLER_10_416 VGND VGND VPWR VPWR sky130_fd_sc_hd__decap_3
XFILLER_22_265 VGND VGND VPWR VPWR sky130_fd_sc_hd__decap_3
X_6787_ _6923_/CLK _6787_/D VGND VGND VPWR VPWR _6787_/Q sky130_fd_sc_hd__dfxtp_2
XFILLER_10_427 VGND VGND VPWR VPWR sky130_fd_sc_hd__fill_1
XFILLER_13_57 VGND VGND VPWR VPWR sky130_fd_sc_hd__decap_3
XFILLER_22_287 VGND VGND VPWR VPWR sky130_fd_sc_hd__fill_1
XFILLER_13_79 VGND VGND VPWR VPWR sky130_fd_sc_hd__fill_1
XTAP_TAPCELL_ROW_79_1243 VGND VPWR sky130_fd_sc_hd__tapvpwrvgnd_1
XFILLER_2_604 VGND VGND VPWR VPWR sky130_fd_sc_hd__decap_3
XTAP_TAPCELL_ROW_92_1410 VGND VPWR sky130_fd_sc_hd__tapvpwrvgnd_1
XFILLER_116_381 VGND VGND VPWR VPWR sky130_fd_sc_hd__fill_2
XFILLER_1_103 VGND VGND VPWR VPWR sky130_fd_sc_hd__fill_1
XFILLER_2_637 VGND VGND VPWR VPWR sky130_fd_sc_hd__decap_3
XFILLER_2_648 VGND VGND VPWR VPWR sky130_fd_sc_hd__decap_3
XFILLER_89_221 VGND VGND VPWR VPWR sky130_fd_sc_hd__decap_3
X_7339_ _7371_/CLK _7339_/D _6619_/Y VGND VGND VPWR VPWR _7339_/Q sky130_fd_sc_hd__dfrtp_2
XFILLER_77_405 VGND VGND VPWR VPWR sky130_fd_sc_hd__decap_3
XFILLER_89_265 VGND VGND VPWR VPWR sky130_fd_sc_hd__decap_3
XFILLER_104_576 VGND VGND VPWR VPWR sky130_fd_sc_hd__decap_3
XFILLER_104_598 VGND VGND VPWR VPWR sky130_fd_sc_hd__decap_3
XFILLER_1_169 VGND VGND VPWR VPWR sky130_fd_sc_hd__decap_3
XFILLER_38_21 VGND VGND VPWR VPWR sky130_fd_sc_hd__decap_3
XFILLER_77_438 VGND VGND VPWR VPWR sky130_fd_sc_hd__fill_1
XFILLER_89_298 VGND VGND VPWR VPWR sky130_fd_sc_hd__decap_3
XFILLER_38_32 VGND VGND VPWR VPWR sky130_fd_sc_hd__fill_1
XFILLER_77_449 VGND VGND VPWR VPWR sky130_fd_sc_hd__decap_3
XFILLER_18_516 VGND VGND VPWR VPWR sky130_fd_sc_hd__decap_3
XFILLER_38_76 VGND VGND VPWR VPWR sky130_fd_sc_hd__decap_3
XFILLER_57_140 VGND VGND VPWR VPWR sky130_fd_sc_hd__decap_3
XFILLER_58_663 VGND VGND VPWR VPWR sky130_fd_sc_hd__decap_3
Xhold1150 _7376_/Q VGND VGND VPWR VPWR _3924_/A1 sky130_fd_sc_hd__dlygate4sd3_1
XFILLER_18_549 VGND VGND VPWR VPWR sky130_fd_sc_hd__decap_3
XFILLER_58_696 VGND VGND VPWR VPWR sky130_fd_sc_hd__decap_3
XFILLER_73_644 VGND VGND VPWR VPWR sky130_fd_sc_hd__decap_3
Xhold1161 _7321_/Q VGND VGND VPWR VPWR _4517_/A0 sky130_fd_sc_hd__dlygate4sd3_1
Xhold1172 _7307_/Q VGND VGND VPWR VPWR _4546_/A sky130_fd_sc_hd__dlygate4sd3_1
Xhold1183 _4532_/X VGND VGND VPWR VPWR _7313_/D sky130_fd_sc_hd__dlygate4sd3_1
Xhold1194 _7203_/Q VGND VGND VPWR VPWR _5253_/A0 sky130_fd_sc_hd__dlygate4sd3_1
XFILLER_33_508 VGND VGND VPWR VPWR sky130_fd_sc_hd__decap_3
XFILLER_45_346 VGND VGND VPWR VPWR sky130_fd_sc_hd__decap_3
XFILLER_73_688 VGND VGND VPWR VPWR sky130_fd_sc_hd__decap_3
XFILLER_53_390 VGND VGND VPWR VPWR sky130_fd_sc_hd__fill_2
XFILLER_54_97 VGND VGND VPWR VPWR sky130_fd_sc_hd__fill_2
XFILLER_9_214 VGND VGND VPWR VPWR sky130_fd_sc_hd__fill_1
XTAP_TAPCELL_ROW_11_400 VGND VPWR sky130_fd_sc_hd__tapvpwrvgnd_1
XFILLER_9_258 VGND VGND VPWR VPWR sky130_fd_sc_hd__decap_3
XFILLER_9_247 VGND VGND VPWR VPWR sky130_fd_sc_hd__decap_3
XFILLER_70_85 VGND VGND VPWR VPWR sky130_fd_sc_hd__decap_3
Xclkload17 _6983_/CLK VGND VGND VPWR VPWR clkload17/X sky130_fd_sc_hd__clkbuf_1
Xclkload28 _7406_/CLK VGND VGND VPWR VPWR clkload28/X sky130_fd_sc_hd__clkbuf_16
XFILLER_114_307 VGND VGND VPWR VPWR sky130_fd_sc_hd__fill_1
XFILLER_107_370 VGND VGND VPWR VPWR sky130_fd_sc_hd__decap_3
XFILLER_5_497 VGND VGND VPWR VPWR sky130_fd_sc_hd__decap_3
XFILLER_79_72 VGND VGND VPWR VPWR sky130_fd_sc_hd__decap_3
XFILLER_49_641 VGND VGND VPWR VPWR sky130_fd_sc_hd__decap_3
XFILLER_95_235 VGND VGND VPWR VPWR sky130_fd_sc_hd__decap_3
XFILLER_110_568 VGND VGND VPWR VPWR sky130_fd_sc_hd__fill_1
XFILLER_36_302 VGND VGND VPWR VPWR sky130_fd_sc_hd__decap_3
XFILLER_49_685 VGND VGND VPWR VPWR sky130_fd_sc_hd__decap_3
XFILLER_76_471 VGND VGND VPWR VPWR sky130_fd_sc_hd__decap_3
XFILLER_95_279 VGND VGND VPWR VPWR sky130_fd_sc_hd__fill_1
XFILLER_95_60 VGND VGND VPWR VPWR sky130_fd_sc_hd__decap_3
Xclkbuf_leaf_0_clk clkbuf_leaf_1_clk/A VGND VGND VPWR VPWR _6906_/CLK sky130_fd_sc_hd__clkbuf_16
XFILLER_36_324 VGND VGND VPWR VPWR sky130_fd_sc_hd__decap_3
XFILLER_48_184 VGND VGND VPWR VPWR sky130_fd_sc_hd__decap_3
XFILLER_64_622 VGND VGND VPWR VPWR sky130_fd_sc_hd__decap_3
XFILLER_91_430 VGND VGND VPWR VPWR sky130_fd_sc_hd__decap_3
XTAP_TAPCELL_ROW_19_500 VGND VPWR sky130_fd_sc_hd__tapvpwrvgnd_1
XFILLER_63_143 VGND VGND VPWR VPWR sky130_fd_sc_hd__decap_3
XFILLER_64_666 VGND VGND VPWR VPWR sky130_fd_sc_hd__decap_3
XFILLER_91_452 VGND VGND VPWR VPWR sky130_fd_sc_hd__decap_3
XTAP_TAPCELL_ROW_47_842 VGND VPWR sky130_fd_sc_hd__tapvpwrvgnd_1
XFILLER_51_316 VGND VGND VPWR VPWR sky130_fd_sc_hd__decap_3
XFILLER_64_699 VGND VGND VPWR VPWR sky130_fd_sc_hd__fill_1
X_4971_ _4811_/C _4949_/Y _4967_/X _4969_/X _4970_/X VGND VGND VPWR VPWR _5661_/B
+ sky130_fd_sc_hd__a311oi_2
XFILLER_17_593 VGND VGND VPWR VPWR sky130_fd_sc_hd__decap_3
XFILLER_63_198 VGND VGND VPWR VPWR sky130_fd_sc_hd__fill_1
X_6710_ _6944_/CLK _6710_/D VGND VGND VPWR VPWR _6710_/Q sky130_fd_sc_hd__dfxtp_2
X_3922_ _6778_/Q _3922_/A2 _3922_/B1 _6866_/Q _3921_/X VGND VGND VPWR VPWR _3922_/X
+ sky130_fd_sc_hd__a221o_2
XTAP_TAPCELL_ROW_63_1044 VGND VPWR sky130_fd_sc_hd__tapvpwrvgnd_1
XFILLER_32_585 VGND VGND VPWR VPWR sky130_fd_sc_hd__decap_3
X_6641_ _6641_/A VGND VGND VPWR VPWR _6641_/Y sky130_fd_sc_hd__inv_2
X_3853_ _6736_/Q _3853_/A2 _3656_/Y _6730_/Q _3852_/X VGND VGND VPWR VPWR _3853_/X
+ sky130_fd_sc_hd__a221o_2
XFILLER_118_613 VGND VGND VPWR VPWR sky130_fd_sc_hd__decap_3
X_6572_ _6608_/A VGND VGND VPWR VPWR _6572_/Y sky130_fd_sc_hd__inv_2
X_3784_ _6847_/Q _3661_/X _3850_/B1 _6842_/Q VGND VGND VPWR VPWR _3784_/X sky130_fd_sc_hd__a22o_2
XFILLER_118_657 VGND VGND VPWR VPWR sky130_fd_sc_hd__decap_3
XFILLER_105_307 VGND VGND VPWR VPWR sky130_fd_sc_hd__decap_3
XFILLER_117_178 VGND VGND VPWR VPWR sky130_fd_sc_hd__decap_3
X_4405_ _7242_/Q _4433_/B _3947_/S _7210_/Q VGND VGND VPWR VPWR _4405_/X sky130_fd_sc_hd__a22o_2
XFILLER_113_340 VGND VGND VPWR VPWR sky130_fd_sc_hd__decap_3
XFILLER_87_703 VGND VGND VPWR VPWR sky130_fd_sc_hd__decap_3
X_7124_ _7345_/CLK _7124_/D _6404_/Y VGND VGND VPWR VPWR _7124_/Q sky130_fd_sc_hd__dfrtp_2
Xoutput577 _5662_/A VGND VGND VPWR VPWR alu_result_out[14] sky130_fd_sc_hd__clkdlybuf4s25_1
X_4336_ _4336_/A _4336_/B _4336_/C VGND VGND VPWR VPWR _4336_/X sky130_fd_sc_hd__or3_2
XFILLER_99_541 VGND VGND VPWR VPWR sky130_fd_sc_hd__decap_3
XFILLER_101_524 VGND VGND VPWR VPWR sky130_fd_sc_hd__fill_2
XFILLER_115_15 VGND VGND VPWR VPWR sky130_fd_sc_hd__decap_3
XFILLER_59_405 VGND VGND VPWR VPWR sky130_fd_sc_hd__decap_3
XFILLER_59_427 VGND VGND VPWR VPWR sky130_fd_sc_hd__decap_3
Xoutput599 _3746_/C VGND VGND VPWR VPWR alu_result_out[5] sky130_fd_sc_hd__clkdlybuf4s25_1
Xoutput588 _5657_/A VGND VGND VPWR VPWR alu_result_out[24] sky130_fd_sc_hd__clkdlybuf4s25_1
XTAP_TAPCELL_ROW_74_1184 VGND VPWR sky130_fd_sc_hd__tapvpwrvgnd_1
XFILLER_101_546 VGND VGND VPWR VPWR sky130_fd_sc_hd__decap_3
XFILLER_115_48 VGND VGND VPWR VPWR sky130_fd_sc_hd__decap_3
XFILLER_59_449 VGND VGND VPWR VPWR sky130_fd_sc_hd__decap_3
X_7055_ _7349_/CLK _7055_/D _6335_/Y VGND VGND VPWR VPWR _7055_/Q sky130_fd_sc_hd__dfrtp_2
X_4267_ _7134_/Q _4333_/A2 _4267_/B1 _7166_/Q VGND VGND VPWR VPWR _4271_/B sky130_fd_sc_hd__a22o_2
XFILLER_55_600 VGND VGND VPWR VPWR sky130_fd_sc_hd__decap_3
XFILLER_74_419 VGND VGND VPWR VPWR sky130_fd_sc_hd__fill_1
XFILLER_86_279 VGND VGND VPWR VPWR sky130_fd_sc_hd__decap_3
X_4198_ _4194_/X _4197_/X _4327_/A VGND VGND VPWR VPWR _4380_/B sky130_fd_sc_hd__o21ai_2
XFILLER_27_324 VGND VGND VPWR VPWR sky130_fd_sc_hd__decap_3
XFILLER_39_195 VGND VGND VPWR VPWR sky130_fd_sc_hd__decap_3
XFILLER_55_644 VGND VGND VPWR VPWR sky130_fd_sc_hd__decap_3
XFILLER_15_508 VGND VGND VPWR VPWR sky130_fd_sc_hd__decap_3
XFILLER_27_346 VGND VGND VPWR VPWR sky130_fd_sc_hd__decap_3
XFILLER_27_368 VGND VGND VPWR VPWR sky130_fd_sc_hd__decap_3
XFILLER_54_132 VGND VGND VPWR VPWR sky130_fd_sc_hd__decap_3
XFILLER_94_290 VGND VGND VPWR VPWR sky130_fd_sc_hd__decap_3
XFILLER_15_519 VGND VGND VPWR VPWR sky130_fd_sc_hd__decap_3
XFILLER_42_305 VGND VGND VPWR VPWR sky130_fd_sc_hd__decap_3
XFILLER_42_327 VGND VGND VPWR VPWR sky130_fd_sc_hd__decap_3
XFILLER_54_165 VGND VGND VPWR VPWR sky130_fd_sc_hd__fill_1
XFILLER_55_688 VGND VGND VPWR VPWR sky130_fd_sc_hd__decap_3
XFILLER_70_625 VGND VGND VPWR VPWR sky130_fd_sc_hd__decap_3
XFILLER_82_474 VGND VGND VPWR VPWR sky130_fd_sc_hd__fill_2
XFILLER_23_530 VGND VGND VPWR VPWR sky130_fd_sc_hd__decap_3
XFILLER_70_669 VGND VGND VPWR VPWR sky130_fd_sc_hd__decap_3
X_6908_ clkload9/A _6908_/D VGND VGND VPWR VPWR _6908_/Q sky130_fd_sc_hd__dfxtp_2
XFILLER_11_703 VGND VGND VPWR VPWR sky130_fd_sc_hd__decap_3
XFILLER_23_574 VGND VGND VPWR VPWR sky130_fd_sc_hd__decap_3
X_6839_ clkload3/A _6839_/D VGND VGND VPWR VPWR _6839_/Q sky130_fd_sc_hd__dfxtp_2
XTAP_TAPCELL_ROW_25_569 VGND VPWR sky130_fd_sc_hd__tapvpwrvgnd_1
XFILLER_109_602 VGND VGND VPWR VPWR sky130_fd_sc_hd__decap_3
XFILLER_109_635 VGND VGND VPWR VPWR sky130_fd_sc_hd__decap_3
XFILLER_108_156 VGND VGND VPWR VPWR sky130_fd_sc_hd__decap_3
XFILLER_109_668 VGND VGND VPWR VPWR sky130_fd_sc_hd__decap_3
XFILLER_109_679 VGND VGND VPWR VPWR sky130_fd_sc_hd__decap_3
XFILLER_108_178 VGND VGND VPWR VPWR sky130_fd_sc_hd__decap_3
XFILLER_40_88 VGND VGND VPWR VPWR sky130_fd_sc_hd__decap_3
XFILLER_2_489 VGND VGND VPWR VPWR sky130_fd_sc_hd__decap_3
XFILLER_104_395 VGND VGND VPWR VPWR sky130_fd_sc_hd__decap_3
XFILLER_49_86 VGND VGND VPWR VPWR sky130_fd_sc_hd__decap_3
XFILLER_77_246 VGND VGND VPWR VPWR sky130_fd_sc_hd__decap_3
XFILLER_58_460 VGND VGND VPWR VPWR sky130_fd_sc_hd__decap_3
XFILLER_93_706 VGND VGND VPWR VPWR sky130_fd_sc_hd__decap_3
XFILLER_105_92 VGND VGND VPWR VPWR sky130_fd_sc_hd__decap_3
XFILLER_18_302 VGND VGND VPWR VPWR sky130_fd_sc_hd__decap_3
XFILLER_46_622 VGND VGND VPWR VPWR sky130_fd_sc_hd__decap_3
XFILLER_65_30 VGND VGND VPWR VPWR sky130_fd_sc_hd__decap_3
XFILLER_92_238 VGND VGND VPWR VPWR sky130_fd_sc_hd__decap_3
XFILLER_18_357 VGND VGND VPWR VPWR sky130_fd_sc_hd__decap_3
XFILLER_18_368 VGND VGND VPWR VPWR sky130_fd_sc_hd__decap_3
XFILLER_46_666 VGND VGND VPWR VPWR sky130_fd_sc_hd__decap_3
XFILLER_73_452 VGND VGND VPWR VPWR sky130_fd_sc_hd__decap_3
XFILLER_85_290 VGND VGND VPWR VPWR sky130_fd_sc_hd__decap_3
XFILLER_33_305 VGND VGND VPWR VPWR sky130_fd_sc_hd__decap_3
XFILLER_46_699 VGND VGND VPWR VPWR sky130_fd_sc_hd__fill_1
XFILLER_61_614 VGND VGND VPWR VPWR sky130_fd_sc_hd__fill_2
XFILLER_73_485 VGND VGND VPWR VPWR sky130_fd_sc_hd__decap_3
XTAP_TAPCELL_ROW_44_812 VGND VPWR sky130_fd_sc_hd__tapvpwrvgnd_1
XFILLER_14_530 VGND VGND VPWR VPWR sky130_fd_sc_hd__fill_2
XFILLER_14_541 VGND VGND VPWR VPWR sky130_fd_sc_hd__decap_3
XFILLER_61_647 VGND VGND VPWR VPWR sky130_fd_sc_hd__decap_3
XFILLER_14_585 VGND VGND VPWR VPWR sky130_fd_sc_hd__decap_3
XFILLER_41_393 VGND VGND VPWR VPWR sky130_fd_sc_hd__decap_3
XFILLER_81_95 VGND VGND VPWR VPWR sky130_fd_sc_hd__decap_3
XFILLER_115_605 VGND VGND VPWR VPWR sky130_fd_sc_hd__decap_3
XFILLER_108_690 VGND VGND VPWR VPWR sky130_fd_sc_hd__decap_3
XFILLER_115_638 VGND VGND VPWR VPWR sky130_fd_sc_hd__decap_3
XFILLER_69_703 VGND VGND VPWR VPWR sky130_fd_sc_hd__decap_3
XFILLER_68_213 VGND VGND VPWR VPWR sky130_fd_sc_hd__fill_1
XFILLER_96_522 VGND VGND VPWR VPWR sky130_fd_sc_hd__decap_3
XTAP_TAPCELL_ROW_110_1638 VGND VPWR sky130_fd_sc_hd__tapvpwrvgnd_1
XTAP_TAPCELL_ROW_110_1627 VGND VPWR sky130_fd_sc_hd__tapvpwrvgnd_1
XFILLER_110_321 VGND VGND VPWR VPWR sky130_fd_sc_hd__decap_3
XFILLER_96_533 VGND VGND VPWR VPWR sky130_fd_sc_hd__decap_3
X_4121_ _7140_/Q _4351_/B1 _4267_/B1 _7172_/Q _4120_/X VGND VGND VPWR VPWR _4121_/X
+ sky130_fd_sc_hd__a221o_2
XFILLER_110_365 VGND VGND VPWR VPWR sky130_fd_sc_hd__decap_3
XFILLER_49_460 VGND VGND VPWR VPWR sky130_fd_sc_hd__decap_3
XFILLER_56_419 VGND VGND VPWR VPWR sky130_fd_sc_hd__fill_1
XFILLER_68_268 VGND VGND VPWR VPWR sky130_fd_sc_hd__fill_2
XFILLER_83_205 VGND VGND VPWR VPWR sky130_fd_sc_hd__decap_3
X_4052_ _4047_/X _4050_/X _4425_/A VGND VGND VPWR VPWR _4456_/A sky130_fd_sc_hd__o21a_2
XFILLER_37_611 VGND VGND VPWR VPWR sky130_fd_sc_hd__decap_3
XFILLER_49_471 VGND VGND VPWR VPWR sky130_fd_sc_hd__decap_3
XFILLER_49_482 VGND VGND VPWR VPWR sky130_fd_sc_hd__decap_3
XFILLER_37_644 VGND VGND VPWR VPWR sky130_fd_sc_hd__decap_3
XFILLER_24_316 VGND VGND VPWR VPWR sky130_fd_sc_hd__decap_3
XFILLER_36_176 VGND VGND VPWR VPWR sky130_fd_sc_hd__decap_3
XFILLER_37_688 VGND VGND VPWR VPWR sky130_fd_sc_hd__decap_3
XFILLER_51_102 VGND VGND VPWR VPWR sky130_fd_sc_hd__fill_1
XFILLER_52_625 VGND VGND VPWR VPWR sky130_fd_sc_hd__decap_3
XFILLER_91_271 VGND VGND VPWR VPWR sky130_fd_sc_hd__decap_3
XFILLER_24_338 VGND VGND VPWR VPWR sky130_fd_sc_hd__decap_3
XFILLER_51_146 VGND VGND VPWR VPWR sky130_fd_sc_hd__decap_3
XFILLER_52_669 VGND VGND VPWR VPWR sky130_fd_sc_hd__decap_3
X_4954_ _4200_/A _4969_/C _4953_/Y _4200_/X VGND VGND VPWR VPWR _4954_/X sky130_fd_sc_hd__o211a_2
X_3905_ _3905_/A1 _5104_/A _3904_/Y VGND VGND VPWR VPWR _7380_/D sky130_fd_sc_hd__a21bo_2
XFILLER_20_533 VGND VGND VPWR VPWR sky130_fd_sc_hd__fill_2
XFILLER_32_382 VGND VGND VPWR VPWR sky130_fd_sc_hd__decap_3
X_4885_ _4904_/B _4903_/A VGND VGND VPWR VPWR _4886_/C sky130_fd_sc_hd__and2b_2
XTAP_TAPCELL_ROW_22_539 VGND VPWR sky130_fd_sc_hd__tapvpwrvgnd_1
XTAP_TAPCELL_ROW_22_528 VGND VPWR sky130_fd_sc_hd__tapvpwrvgnd_1
XFILLER_20_544 VGND VGND VPWR VPWR sky130_fd_sc_hd__fill_1
X_6624_ _6624_/A VGND VGND VPWR VPWR _6624_/Y sky130_fd_sc_hd__inv_2
X_3836_ _6970_/Q _3656_/Y _3850_/B1 _6720_/Q _3835_/X VGND VGND VPWR VPWR _3836_/X
+ sky130_fd_sc_hd__a221o_2
XFILLER_20_577 VGND VGND VPWR VPWR sky130_fd_sc_hd__decap_3
X_6555_ _6556_/A VGND VGND VPWR VPWR _6555_/Y sky130_fd_sc_hd__inv_2
X_3767_ _6705_/Q _3925_/A2 _3767_/B1 _6883_/Q VGND VGND VPWR VPWR _3767_/X sky130_fd_sc_hd__a22o_2
XFILLER_106_616 VGND VGND VPWR VPWR sky130_fd_sc_hd__decap_3
XTAP_TAPCELL_ROW_76_1213 VGND VPWR sky130_fd_sc_hd__tapvpwrvgnd_1
XTAP_TAPCELL_ROW_76_1202 VGND VPWR sky130_fd_sc_hd__tapvpwrvgnd_1
X_6486_ _6550_/A VGND VGND VPWR VPWR _6486_/Y sky130_fd_sc_hd__inv_2
X_3698_ _3698_/A1 _4832_/A _3697_/Y VGND VGND VPWR VPWR _7402_/D sky130_fd_sc_hd__o21ba_2
XFILLER_105_159 VGND VGND VPWR VPWR sky130_fd_sc_hd__decap_3
XFILLER_10_47 VGND VGND VPWR VPWR sky130_fd_sc_hd__fill_1
XFILLER_114_660 VGND VGND VPWR VPWR sky130_fd_sc_hd__decap_3
XFILLER_59_202 VGND VGND VPWR VPWR sky130_fd_sc_hd__decap_3
XFILLER_86_29 VGND VGND VPWR VPWR sky130_fd_sc_hd__decap_3
XFILLER_87_500 VGND VGND VPWR VPWR sky130_fd_sc_hd__decap_3
XFILLER_101_310 VGND VGND VPWR VPWR sky130_fd_sc_hd__decap_3
XFILLER_114_693 VGND VGND VPWR VPWR sky130_fd_sc_hd__decap_3
X_7107_ _7370_/CLK _7107_/D _6387_/Y VGND VGND VPWR VPWR _7107_/Q sky130_fd_sc_hd__dfrtp_2
X_4319_ _7258_/Q _4601_/S _4316_/X _4318_/X VGND VGND VPWR VPWR _4362_/A sky130_fd_sc_hd__a211o_2
XFILLER_101_343 VGND VGND VPWR VPWR sky130_fd_sc_hd__decap_3
XFILLER_75_706 VGND VGND VPWR VPWR sky130_fd_sc_hd__decap_3
X_7038_ _7387_/CLK _7038_/D _6318_/Y VGND VGND VPWR VPWR _7038_/Q sky130_fd_sc_hd__dfrtp_2
XFILLER_19_89 VGND VGND VPWR VPWR sky130_fd_sc_hd__decap_3
XFILLER_28_622 VGND VGND VPWR VPWR sky130_fd_sc_hd__decap_3
XFILLER_27_143 VGND VGND VPWR VPWR sky130_fd_sc_hd__fill_1
XFILLER_28_666 VGND VGND VPWR VPWR sky130_fd_sc_hd__decap_3
XFILLER_55_452 VGND VGND VPWR VPWR sky130_fd_sc_hd__fill_2
XTAP_TAPCELL_ROW_87_1342 VGND VPWR sky130_fd_sc_hd__tapvpwrvgnd_1
XFILLER_15_305 VGND VGND VPWR VPWR sky130_fd_sc_hd__decap_3
XFILLER_15_327 VGND VGND VPWR VPWR sky130_fd_sc_hd__decap_3
XFILLER_28_699 VGND VGND VPWR VPWR sky130_fd_sc_hd__fill_1
XFILLER_35_11 VGND VGND VPWR VPWR sky130_fd_sc_hd__fill_1
XFILLER_43_603 VGND VGND VPWR VPWR sky130_fd_sc_hd__decap_3
XTAP_TAPCELL_ROW_2_286 VGND VPWR sky130_fd_sc_hd__tapvpwrvgnd_1
XFILLER_27_198 VGND VGND VPWR VPWR sky130_fd_sc_hd__decap_3
XFILLER_35_55 VGND VGND VPWR VPWR sky130_fd_sc_hd__fill_1
XFILLER_35_66 VGND VGND VPWR VPWR sky130_fd_sc_hd__fill_1
XFILLER_43_647 VGND VGND VPWR VPWR sky130_fd_sc_hd__decap_3
XFILLER_55_496 VGND VGND VPWR VPWR sky130_fd_sc_hd__decap_3
XFILLER_70_433 VGND VGND VPWR VPWR sky130_fd_sc_hd__fill_2
XFILLER_70_444 VGND VGND VPWR VPWR sky130_fd_sc_hd__fill_2
XFILLER_82_282 VGND VGND VPWR VPWR sky130_fd_sc_hd__decap_3
XFILLER_70_488 VGND VGND VPWR VPWR sky130_fd_sc_hd__decap_3
XFILLER_23_393 VGND VGND VPWR VPWR sky130_fd_sc_hd__fill_1
XFILLER_51_21 VGND VGND VPWR VPWR sky130_fd_sc_hd__fill_1
XFILLER_51_691 VGND VGND VPWR VPWR sky130_fd_sc_hd__decap_3
XFILLER_11_544 VGND VGND VPWR VPWR sky130_fd_sc_hd__decap_3
XFILLER_11_588 VGND VGND VPWR VPWR sky130_fd_sc_hd__decap_3
XFILLER_7_548 VGND VGND VPWR VPWR sky130_fd_sc_hd__decap_3
XTAP_TAPCELL_ROW_98_1482 VGND VPWR sky130_fd_sc_hd__tapvpwrvgnd_1
XFILLER_109_487 VGND VGND VPWR VPWR sky130_fd_sc_hd__fill_1
XFILLER_105_671 VGND VGND VPWR VPWR sky130_fd_sc_hd__fill_1
XFILLER_105_682 VGND VGND VPWR VPWR sky130_fd_sc_hd__decap_3
XFILLER_112_619 VGND VGND VPWR VPWR sky130_fd_sc_hd__decap_3
XFILLER_2_253 VGND VGND VPWR VPWR sky130_fd_sc_hd__decap_3
XFILLER_2_264 VGND VGND VPWR VPWR sky130_fd_sc_hd__decap_3
XFILLER_78_511 VGND VGND VPWR VPWR sky130_fd_sc_hd__decap_3
XFILLER_104_192 VGND VGND VPWR VPWR sky130_fd_sc_hd__decap_3
XFILLER_78_533 VGND VGND VPWR VPWR sky130_fd_sc_hd__decap_3
XFILLER_116_80 VGND VGND VPWR VPWR sky130_fd_sc_hd__decap_3
XFILLER_116_91 VGND VGND VPWR VPWR sky130_fd_sc_hd__decap_3
XFILLER_93_514 VGND VGND VPWR VPWR sky130_fd_sc_hd__fill_1
Xsingle_cycle_cpu_678 VGND VGND VPWR VPWR single_cycle_cpu_678/HI instruction_out[29]
+ sky130_fd_sc_hd__conb_1
XFILLER_19_644 VGND VGND VPWR VPWR sky130_fd_sc_hd__decap_3
XFILLER_46_441 VGND VGND VPWR VPWR sky130_fd_sc_hd__decap_3
XFILLER_65_249 VGND VGND VPWR VPWR sky130_fd_sc_hd__decap_3
XFILLER_81_709 VGND VGND VPWR VPWR sky130_fd_sc_hd__decap_3
XFILLER_18_176 VGND VGND VPWR VPWR sky130_fd_sc_hd__decap_3
XFILLER_19_688 VGND VGND VPWR VPWR sky130_fd_sc_hd__decap_3
XFILLER_34_625 VGND VGND VPWR VPWR sky130_fd_sc_hd__decap_3
XFILLER_46_474 VGND VGND VPWR VPWR sky130_fd_sc_hd__fill_2
XFILLER_80_219 VGND VGND VPWR VPWR sky130_fd_sc_hd__decap_3
XTAP_TAPCELL_ROW_57_970 VGND VPWR sky130_fd_sc_hd__tapvpwrvgnd_1
XFILLER_33_113 VGND VGND VPWR VPWR sky130_fd_sc_hd__decap_3
XFILLER_34_669 VGND VGND VPWR VPWR sky130_fd_sc_hd__decap_3
XFILLER_92_72 VGND VGND VPWR VPWR sky130_fd_sc_hd__decap_3
XFILLER_61_466 VGND VGND VPWR VPWR sky130_fd_sc_hd__decap_3
XFILLER_61_477 VGND VGND VPWR VPWR sky130_fd_sc_hd__decap_3
XFILLER_92_94 VGND VGND VPWR VPWR sky130_fd_sc_hd__decap_3
XFILLER_61_499 VGND VGND VPWR VPWR sky130_fd_sc_hd__decap_3
XTAP_TAPCELL_ROW_60_1014 VGND VPWR sky130_fd_sc_hd__tapvpwrvgnd_1
XTAP_TAPCELL_ROW_60_1003 VGND VPWR sky130_fd_sc_hd__tapvpwrvgnd_1
X_4670_ _6995_/Q _4690_/B VGND VGND VPWR VPWR _4682_/B sky130_fd_sc_hd__or2_2
X_3621_ _3621_/A _3621_/B VGND VGND VPWR VPWR _4852_/A sky130_fd_sc_hd__nand2_2
X_6340_ _6463_/A VGND VGND VPWR VPWR _6340_/Y sky130_fd_sc_hd__inv_2
X_3552_ _3508_/Y _5020_/A _3620_/A _3537_/X _3551_/X VGND VGND VPWR VPWR _3746_/A
+ sky130_fd_sc_hd__o311a_2
XFILLER_6_581 VGND VGND VPWR VPWR sky130_fd_sc_hd__decap_3
XFILLER_115_457 VGND VGND VPWR VPWR sky130_fd_sc_hd__decap_3
XFILLER_6_592 VGND VGND VPWR VPWR sky130_fd_sc_hd__decap_3
X_6271_ _6678_/A VGND VGND VPWR VPWR _6271_/Y sky130_fd_sc_hd__inv_2
X_3483_ _3442_/A _3442_/B _3409_/D VGND VGND VPWR VPWR _5153_/B sky130_fd_sc_hd__a21o_2
XFILLER_102_118 VGND VGND VPWR VPWR sky130_fd_sc_hd__decap_3
XPHY_EDGE_ROW_102_Left_222 VGND VGND VPWR VPWR sky130_fd_sc_hd__decap_3
X_5153_ _7010_/D _5153_/B VGND VGND VPWR VPWR _5153_/X sky130_fd_sc_hd__xor2_2
XTAP_TAPCELL_ROW_71_1143 VGND VPWR sky130_fd_sc_hd__tapvpwrvgnd_1
XFILLER_111_641 VGND VGND VPWR VPWR sky130_fd_sc_hd__decap_3
XFILLER_29_408 VGND VGND VPWR VPWR sky130_fd_sc_hd__decap_3
XFILLER_57_706 VGND VGND VPWR VPWR sky130_fd_sc_hd__decap_3
XFILLER_69_555 VGND VGND VPWR VPWR sky130_fd_sc_hd__decap_3
XFILLER_96_352 VGND VGND VPWR VPWR sky130_fd_sc_hd__decap_3
X_4104_ _7237_/Q _4353_/A2 _4244_/B _7050_/Q VGND VGND VPWR VPWR _4104_/X sky130_fd_sc_hd__a22o_2
XFILLER_111_685 VGND VGND VPWR VPWR sky130_fd_sc_hd__decap_3
XFILLER_96_374 VGND VGND VPWR VPWR sky130_fd_sc_hd__decap_3
X_5084_ _4343_/X _5084_/B _5086_/A VGND VGND VPWR VPWR _5084_/X sky130_fd_sc_hd__and3b_2
XFILLER_110_195 VGND VGND VPWR VPWR sky130_fd_sc_hd__fill_1
XFILLER_37_441 VGND VGND VPWR VPWR sky130_fd_sc_hd__decap_3
XFILLER_49_290 VGND VGND VPWR VPWR sky130_fd_sc_hd__decap_3
X_4035_ _7374_/Q _4416_/A2 _4436_/B1 _7182_/Q _4034_/X VGND VGND VPWR VPWR _4035_/X
+ sky130_fd_sc_hd__a221o_2
XFILLER_112_27 VGND VGND VPWR VPWR sky130_fd_sc_hd__fill_1
XFILLER_112_38 VGND VGND VPWR VPWR sky130_fd_sc_hd__decap_3
XFILLER_37_463 VGND VGND VPWR VPWR sky130_fd_sc_hd__decap_3
XFILLER_71_208 VGND VGND VPWR VPWR sky130_fd_sc_hd__decap_3
XFILLER_24_135 VGND VGND VPWR VPWR sky130_fd_sc_hd__decap_3
XFILLER_25_647 VGND VGND VPWR VPWR sky130_fd_sc_hd__decap_3
XFILLER_52_433 VGND VGND VPWR VPWR sky130_fd_sc_hd__decap_3
XFILLER_24_168 VGND VGND VPWR VPWR sky130_fd_sc_hd__decap_3
XFILLER_52_477 VGND VGND VPWR VPWR sky130_fd_sc_hd__fill_1
XPHY_EDGE_ROW_111_Left_231 VGND VGND VPWR VPWR sky130_fd_sc_hd__decap_3
XFILLER_33_691 VGND VGND VPWR VPWR sky130_fd_sc_hd__decap_3
XFILLER_40_628 VGND VGND VPWR VPWR sky130_fd_sc_hd__decap_3
X_4937_ _4937_/A _4937_/B VGND VGND VPWR VPWR _4937_/Y sky130_fd_sc_hd__xnor2_2
XTAP_TAPCELL_ROW_82_1283 VGND VPWR sky130_fd_sc_hd__tapvpwrvgnd_1
XTAP_TAPCELL_ROW_35_697 VGND VPWR sky130_fd_sc_hd__tapvpwrvgnd_1
XFILLER_20_330 VGND VGND VPWR VPWR sky130_fd_sc_hd__decap_3
X_4868_ _6999_/Q _4882_/A VGND VGND VPWR VPWR _6999_/D sky130_fd_sc_hd__xnor2_2
XFILLER_20_374 VGND VGND VPWR VPWR sky130_fd_sc_hd__decap_3
X_6607_ _6639_/A VGND VGND VPWR VPWR _6607_/Y sky130_fd_sc_hd__inv_2
X_3819_ _6791_/Q _3926_/B1 _3925_/B1 _6879_/Q VGND VGND VPWR VPWR _3819_/X sky130_fd_sc_hd__a22o_2
XFILLER_21_46 VGND VGND VPWR VPWR sky130_fd_sc_hd__decap_3
XFILLER_4_507 VGND VGND VPWR VPWR sky130_fd_sc_hd__fill_1
X_4799_ _4799_/A _5656_/A VGND VGND VPWR VPWR _4799_/X sky130_fd_sc_hd__or2_2
XFILLER_106_413 VGND VGND VPWR VPWR sky130_fd_sc_hd__decap_3
XFILLER_106_424 VGND VGND VPWR VPWR sky130_fd_sc_hd__decap_3
XFILLER_118_262 VGND VGND VPWR VPWR sky130_fd_sc_hd__decap_3
XFILLER_21_57 VGND VGND VPWR VPWR sky130_fd_sc_hd__decap_3
XFILLER_4_518 VGND VGND VPWR VPWR sky130_fd_sc_hd__decap_3
X_6538_ _6638_/A VGND VGND VPWR VPWR _6538_/Y sky130_fd_sc_hd__inv_2
XFILLER_106_457 VGND VGND VPWR VPWR sky130_fd_sc_hd__decap_3
XFILLER_108_6 VGND VGND VPWR VPWR sky130_fd_sc_hd__decap_3
XFILLER_97_28 VGND VGND VPWR VPWR sky130_fd_sc_hd__decap_3
X_6469_ _6662_/A VGND VGND VPWR VPWR _6469_/Y sky130_fd_sc_hd__inv_2
XTAP_TAPCELL_ROW_7_345 VGND VPWR sky130_fd_sc_hd__tapvpwrvgnd_1
XFILLER_101_140 VGND VGND VPWR VPWR sky130_fd_sc_hd__decap_3
XFILLER_102_663 VGND VGND VPWR VPWR sky130_fd_sc_hd__decap_3
XFILLER_87_352 VGND VGND VPWR VPWR sky130_fd_sc_hd__decap_3
XPHY_EDGE_ROW_102_Right_102 VGND VGND VPWR VPWR sky130_fd_sc_hd__decap_3
XFILLER_102_696 VGND VGND VPWR VPWR sky130_fd_sc_hd__decap_3
XFILLER_47_205 VGND VGND VPWR VPWR sky130_fd_sc_hd__decap_3
XFILLER_87_396 VGND VGND VPWR VPWR sky130_fd_sc_hd__fill_2
XFILLER_101_184 VGND VGND VPWR VPWR sky130_fd_sc_hd__decap_3
XFILLER_28_430 VGND VGND VPWR VPWR sky130_fd_sc_hd__decap_3
XFILLER_47_249 VGND VGND VPWR VPWR sky130_fd_sc_hd__decap_3
XFILLER_63_709 VGND VGND VPWR VPWR sky130_fd_sc_hd__decap_3
XFILLER_75_558 VGND VGND VPWR VPWR sky130_fd_sc_hd__fill_2
XFILLER_16_625 VGND VGND VPWR VPWR sky130_fd_sc_hd__decap_3
XFILLER_62_208 VGND VGND VPWR VPWR sky130_fd_sc_hd__decap_3
XFILLER_15_102 VGND VGND VPWR VPWR sky130_fd_sc_hd__decap_3
XFILLER_15_113 VGND VGND VPWR VPWR sky130_fd_sc_hd__decap_3
XFILLER_43_422 VGND VGND VPWR VPWR sky130_fd_sc_hd__decap_3
XFILLER_55_293 VGND VGND VPWR VPWR sky130_fd_sc_hd__fill_2
XFILLER_83_591 VGND VGND VPWR VPWR sky130_fd_sc_hd__decap_3
XFILLER_102_71 VGND VGND VPWR VPWR sky130_fd_sc_hd__decap_3
XFILLER_16_669 VGND VGND VPWR VPWR sky130_fd_sc_hd__decap_3
XFILLER_31_617 VGND VGND VPWR VPWR sky130_fd_sc_hd__decap_3
XFILLER_43_455 VGND VGND VPWR VPWR sky130_fd_sc_hd__decap_3
XFILLER_43_488 VGND VGND VPWR VPWR sky130_fd_sc_hd__decap_3
XFILLER_70_296 VGND VGND VPWR VPWR sky130_fd_sc_hd__decap_3
XFILLER_23_190 VGND VGND VPWR VPWR sky130_fd_sc_hd__fill_1
XFILLER_30_149 VGND VGND VPWR VPWR sky130_fd_sc_hd__decap_3
XFILLER_11_385 VGND VGND VPWR VPWR sky130_fd_sc_hd__decap_3
XFILLER_11_396 VGND VGND VPWR VPWR sky130_fd_sc_hd__decap_3
XFILLER_7_389 VGND VGND VPWR VPWR sky130_fd_sc_hd__decap_3
XFILLER_3_573 VGND VGND VPWR VPWR sky130_fd_sc_hd__decap_3
XFILLER_98_639 VGND VGND VPWR VPWR sky130_fd_sc_hd__decap_3
XFILLER_39_706 VGND VGND VPWR VPWR sky130_fd_sc_hd__decap_3
XFILLER_78_341 VGND VGND VPWR VPWR sky130_fd_sc_hd__fill_1
XFILLER_78_363 VGND VGND VPWR VPWR sky130_fd_sc_hd__fill_1
XFILLER_87_72 VGND VGND VPWR VPWR sky130_fd_sc_hd__decap_3
XFILLER_87_94 VGND VGND VPWR VPWR sky130_fd_sc_hd__decap_3
XFILLER_66_514 VGND VGND VPWR VPWR sky130_fd_sc_hd__decap_3
XFILLER_93_311 VGND VGND VPWR VPWR sky130_fd_sc_hd__decap_3
XFILLER_19_430 VGND VGND VPWR VPWR sky130_fd_sc_hd__decap_3
XFILLER_38_238 VGND VGND VPWR VPWR sky130_fd_sc_hd__decap_3
XFILLER_66_569 VGND VGND VPWR VPWR sky130_fd_sc_hd__decap_3
XFILLER_93_333 VGND VGND VPWR VPWR sky130_fd_sc_hd__decap_3
XFILLER_19_452 VGND VGND VPWR VPWR sky130_fd_sc_hd__decap_3
XFILLER_53_219 VGND VGND VPWR VPWR sky130_fd_sc_hd__decap_3
XFILLER_81_528 VGND VGND VPWR VPWR sky130_fd_sc_hd__fill_2
XFILLER_19_485 VGND VGND VPWR VPWR sky130_fd_sc_hd__decap_3
XFILLER_93_399 VGND VGND VPWR VPWR sky130_fd_sc_hd__fill_2
XFILLER_34_444 VGND VGND VPWR VPWR sky130_fd_sc_hd__fill_1
XFILLER_34_477 VGND VGND VPWR VPWR sky130_fd_sc_hd__decap_3
XFILLER_15_691 VGND VGND VPWR VPWR sky130_fd_sc_hd__decap_3
XFILLER_21_116 VGND VGND VPWR VPWR sky130_fd_sc_hd__decap_3
XFILLER_22_628 VGND VGND VPWR VPWR sky130_fd_sc_hd__decap_3
XTAP_TAPCELL_ROW_32_656 VGND VPWR sky130_fd_sc_hd__tapvpwrvgnd_1
XFILLER_30_672 VGND VGND VPWR VPWR sky130_fd_sc_hd__decap_3
X_4653_ _4648_/Y _4785_/A _4413_/A _4397_/A VGND VGND VPWR VPWR _4653_/Y sky130_fd_sc_hd__a211oi_2
X_7372_ _7372_/CLK _7372_/D _6652_/Y VGND VGND VPWR VPWR _7372_/Q sky130_fd_sc_hd__dfrtp_2
Xhold802 _6805_/Q VGND VGND VPWR VPWR _6805_/D sky130_fd_sc_hd__dlygate4sd3_1
X_3604_ _4938_/A _5072_/A VGND VGND VPWR VPWR _3621_/B sky130_fd_sc_hd__nor2_2
Xhold813 _6728_/Q VGND VGND VPWR VPWR _6728_/D sky130_fd_sc_hd__dlygate4sd3_1
Xhold824 _6807_/Q VGND VGND VPWR VPWR _6807_/D sky130_fd_sc_hd__dlygate4sd3_1
Xhold835 _6842_/Q VGND VGND VPWR VPWR _6842_/D sky130_fd_sc_hd__dlygate4sd3_1
Xhold846 _6936_/Q VGND VGND VPWR VPWR _6936_/D sky130_fd_sc_hd__dlygate4sd3_1
X_6323_ _6544_/A VGND VGND VPWR VPWR _6323_/Y sky130_fd_sc_hd__inv_2
X_3535_ _3621_/A _5071_/A _4764_/B VGND VGND VPWR VPWR _3536_/B sky130_fd_sc_hd__and3_2
XFILLER_107_38 VGND VGND VPWR VPWR sky130_fd_sc_hd__decap_3
XFILLER_89_617 VGND VGND VPWR VPWR sky130_fd_sc_hd__decap_3
Xhold857 _6780_/Q VGND VGND VPWR VPWR _6780_/D sky130_fd_sc_hd__dlygate4sd3_1
Xhold868 _6784_/Q VGND VGND VPWR VPWR _6784_/D sky130_fd_sc_hd__dlygate4sd3_1
Xhold879 _6817_/Q VGND VGND VPWR VPWR _6817_/D sky130_fd_sc_hd__dlygate4sd3_1
X_3466_ _7217_/Q _4307_/A2 _4532_/S _7030_/Q _3465_/X VGND VGND VPWR VPWR _3466_/X
+ sky130_fd_sc_hd__a221o_2
XFILLER_103_438 VGND VGND VPWR VPWR sky130_fd_sc_hd__decap_3
XFILLER_103_449 VGND VGND VPWR VPWR sky130_fd_sc_hd__decap_3
XFILLER_88_138 VGND VGND VPWR VPWR sky130_fd_sc_hd__fill_2
X_5205_ _5205_/A _5211_/B VGND VGND VPWR VPWR _7226_/D sky130_fd_sc_hd__and2_2
XFILLER_69_330 VGND VGND VPWR VPWR sky130_fd_sc_hd__decap_3
XFILLER_69_352 VGND VGND VPWR VPWR sky130_fd_sc_hd__decap_3
XFILLER_97_650 VGND VGND VPWR VPWR sky130_fd_sc_hd__decap_3
XTAP_TAPCELL_ROW_4_304 VGND VPWR sky130_fd_sc_hd__tapvpwrvgnd_1
XFILLER_29_205 VGND VGND VPWR VPWR sky130_fd_sc_hd__decap_3
XFILLER_57_514 VGND VGND VPWR VPWR sky130_fd_sc_hd__decap_3
XFILLER_96_171 VGND VGND VPWR VPWR sky130_fd_sc_hd__decap_3
XFILLER_97_694 VGND VGND VPWR VPWR sky130_fd_sc_hd__decap_3
X_5136_ _5136_/A0 _5135_/X _5136_/S VGND VGND VPWR VPWR _7251_/D sky130_fd_sc_hd__mux2_2
XFILLER_29_249 VGND VGND VPWR VPWR sky130_fd_sc_hd__decap_3
XFILLER_45_709 VGND VGND VPWR VPWR sky130_fd_sc_hd__decap_3
XFILLER_84_344 VGND VGND VPWR VPWR sky130_fd_sc_hd__decap_3
X_5067_ _5648_/A _5067_/B VGND VGND VPWR VPWR _5068_/C sky130_fd_sc_hd__or2_2
XFILLER_37_260 VGND VGND VPWR VPWR sky130_fd_sc_hd__decap_3
X_4018_ _7150_/Q _4428_/B1 _4011_/X _4017_/X VGND VGND VPWR VPWR _4018_/X sky130_fd_sc_hd__a211o_2
XFILLER_16_24 VGND VGND VPWR VPWR sky130_fd_sc_hd__decap_3
XFILLER_72_539 VGND VGND VPWR VPWR sky130_fd_sc_hd__decap_3
XFILLER_84_399 VGND VGND VPWR VPWR sky130_fd_sc_hd__decap_3
XTAP_TAPCELL_ROW_84_1312 VGND VPWR sky130_fd_sc_hd__tapvpwrvgnd_1
XFILLER_13_606 VGND VGND VPWR VPWR sky130_fd_sc_hd__decap_3
XFILLER_13_617 VGND VGND VPWR VPWR sky130_fd_sc_hd__decap_3
XFILLER_52_230 VGND VGND VPWR VPWR sky130_fd_sc_hd__decap_3
XFILLER_16_79 VGND VGND VPWR VPWR sky130_fd_sc_hd__decap_3
XFILLER_52_285 VGND VGND VPWR VPWR sky130_fd_sc_hd__decap_3
XFILLER_80_583 VGND VGND VPWR VPWR sky130_fd_sc_hd__decap_3
XFILLER_40_469 VGND VGND VPWR VPWR sky130_fd_sc_hd__decap_3
XFILLER_21_650 VGND VGND VPWR VPWR sky130_fd_sc_hd__decap_3
XFILLER_21_694 VGND VGND VPWR VPWR sky130_fd_sc_hd__decap_3
XFILLER_32_89 VGND VGND VPWR VPWR sky130_fd_sc_hd__fill_1
XFILLER_107_700 VGND VGND VPWR VPWR sky130_fd_sc_hd__decap_3
XFILLER_119_582 VGND VGND VPWR VPWR sky130_fd_sc_hd__decap_3
XFILLER_4_315 VGND VGND VPWR VPWR sky130_fd_sc_hd__decap_3
XTAP_TAPCELL_ROW_95_1441 VGND VPWR sky130_fd_sc_hd__tapvpwrvgnd_1
XFILLER_106_265 VGND VGND VPWR VPWR sky130_fd_sc_hd__decap_3
XFILLER_106_298 VGND VGND VPWR VPWR sky130_fd_sc_hd__decap_3
XFILLER_79_116 VGND VGND VPWR VPWR sky130_fd_sc_hd__decap_3
XFILLER_79_149 VGND VGND VPWR VPWR sky130_fd_sc_hd__decap_3
XFILLER_0_576 VGND VGND VPWR VPWR sky130_fd_sc_hd__decap_3
XFILLER_48_536 VGND VGND VPWR VPWR sky130_fd_sc_hd__decap_3
XFILLER_57_20 VGND VGND VPWR VPWR sky130_fd_sc_hd__decap_3
XFILLER_88_672 VGND VGND VPWR VPWR sky130_fd_sc_hd__decap_3
XFILLER_48_558 VGND VGND VPWR VPWR sky130_fd_sc_hd__decap_3
XFILLER_57_86 VGND VGND VPWR VPWR sky130_fd_sc_hd__decap_3
XFILLER_87_193 VGND VGND VPWR VPWR sky130_fd_sc_hd__decap_3
XFILLER_35_208 VGND VGND VPWR VPWR sky130_fd_sc_hd__decap_3
XFILLER_75_388 VGND VGND VPWR VPWR sky130_fd_sc_hd__decap_3
XFILLER_113_81 VGND VGND VPWR VPWR sky130_fd_sc_hd__decap_3
XFILLER_16_411 VGND VGND VPWR VPWR sky130_fd_sc_hd__decap_3
XFILLER_28_282 VGND VGND VPWR VPWR sky130_fd_sc_hd__decap_3
XFILLER_75_399 VGND VGND VPWR VPWR sky130_fd_sc_hd__decap_3
XFILLER_90_336 VGND VGND VPWR VPWR sky130_fd_sc_hd__decap_3
Xplace506 _6982_/Q VGND VGND VPWR VPWR _3330_/A sky130_fd_sc_hd__buf_2
Xplace517 _6621_/A VGND VGND VPWR VPWR _6288_/A sky130_fd_sc_hd__buf_2
Xplace528 _6617_/A VGND VGND VPWR VPWR _6554_/A sky130_fd_sc_hd__buf_2
XFILLER_71_561 VGND VGND VPWR VPWR sky130_fd_sc_hd__fill_2
XFILLER_73_74 VGND VGND VPWR VPWR sky130_fd_sc_hd__decap_3
Xplace539 _6667_/A VGND VGND VPWR VPWR _6672_/A sky130_fd_sc_hd__buf_2
XFILLER_16_477 VGND VGND VPWR VPWR sky130_fd_sc_hd__decap_3
XFILLER_71_583 VGND VGND VPWR VPWR sky130_fd_sc_hd__decap_3
XFILLER_71_594 VGND VGND VPWR VPWR sky130_fd_sc_hd__fill_1
XFILLER_31_447 VGND VGND VPWR VPWR sky130_fd_sc_hd__fill_1
XFILLER_43_296 VGND VGND VPWR VPWR sky130_fd_sc_hd__decap_3
XFILLER_12_672 VGND VGND VPWR VPWR sky130_fd_sc_hd__decap_3
XFILLER_8_610 VGND VGND VPWR VPWR sky130_fd_sc_hd__decap_3
XFILLER_8_643 VGND VGND VPWR VPWR sky130_fd_sc_hd__fill_1
XFILLER_8_654 VGND VGND VPWR VPWR sky130_fd_sc_hd__decap_3
XFILLER_7_153 VGND VGND VPWR VPWR sky130_fd_sc_hd__decap_3
XFILLER_8_687 VGND VGND VPWR VPWR sky130_fd_sc_hd__decap_3
XFILLER_7_197 VGND VGND VPWR VPWR sky130_fd_sc_hd__decap_3
XFILLER_113_703 VGND VGND VPWR VPWR sky130_fd_sc_hd__decap_3
XFILLER_98_403 VGND VGND VPWR VPWR sky130_fd_sc_hd__decap_3
X_3320_ _5647_/B VGND VGND VPWR VPWR _3326_/A sky130_fd_sc_hd__inv_2
XFILLER_98_71 VGND VGND VPWR VPWR sky130_fd_sc_hd__decap_3
XFILLER_100_408 VGND VGND VPWR VPWR sky130_fd_sc_hd__decap_3
XFILLER_112_268 VGND VGND VPWR VPWR sky130_fd_sc_hd__decap_3
XFILLER_79_650 VGND VGND VPWR VPWR sky130_fd_sc_hd__decap_3
XFILLER_98_469 VGND VGND VPWR VPWR sky130_fd_sc_hd__fill_2
XFILLER_39_514 VGND VGND VPWR VPWR sky130_fd_sc_hd__decap_3
XFILLER_66_300 VGND VGND VPWR VPWR sky130_fd_sc_hd__decap_3
XFILLER_78_160 VGND VGND VPWR VPWR sky130_fd_sc_hd__decap_3
XFILLER_79_694 VGND VGND VPWR VPWR sky130_fd_sc_hd__decap_3
XFILLER_85_108 VGND VGND VPWR VPWR sky130_fd_sc_hd__decap_3
XFILLER_85_119 VGND VGND VPWR VPWR sky130_fd_sc_hd__decap_3
XFILLER_27_709 VGND VGND VPWR VPWR sky130_fd_sc_hd__decap_3
XFILLER_78_193 VGND VGND VPWR VPWR sky130_fd_sc_hd__decap_3
XFILLER_94_631 VGND VGND VPWR VPWR sky130_fd_sc_hd__decap_3
XFILLER_54_528 VGND VGND VPWR VPWR sky130_fd_sc_hd__fill_1
XFILLER_94_675 VGND VGND VPWR VPWR sky130_fd_sc_hd__decap_3
XTAP_TAPCELL_ROW_37_715 VGND VPWR sky130_fd_sc_hd__tapvpwrvgnd_1
XFILLER_19_271 VGND VGND VPWR VPWR sky130_fd_sc_hd__decap_3
XFILLER_19_293 VGND VGND VPWR VPWR sky130_fd_sc_hd__decap_3
XFILLER_93_196 VGND VGND VPWR VPWR sky130_fd_sc_hd__decap_3
X_6941_ _6941_/CLK _6941_/D VGND VGND VPWR VPWR _6941_/Q sky130_fd_sc_hd__dfxtp_2
XTAP_TAPCELL_ROW_37_726 VGND VPWR sky130_fd_sc_hd__tapvpwrvgnd_1
XFILLER_34_241 VGND VGND VPWR VPWR sky130_fd_sc_hd__decap_3
XFILLER_50_701 VGND VGND VPWR VPWR sky130_fd_sc_hd__decap_3
X_6872_ clkload4/A _6872_/D VGND VGND VPWR VPWR _6872_/Q sky130_fd_sc_hd__dfxtp_2
XFILLER_22_414 VGND VGND VPWR VPWR sky130_fd_sc_hd__decap_3
XTAP_TAPCELL_ROW_66_1086 VGND VPWR sky130_fd_sc_hd__tapvpwrvgnd_1
XTAP_TAPCELL_ROW_17_472 VGND VPWR sky130_fd_sc_hd__tapvpwrvgnd_1
XFILLER_22_436 VGND VGND VPWR VPWR sky130_fd_sc_hd__decap_3
XFILLER_108_508 VGND VGND VPWR VPWR sky130_fd_sc_hd__decap_3
XFILLER_30_480 VGND VGND VPWR VPWR sky130_fd_sc_hd__decap_3
X_4705_ _6995_/Q _6996_/Q _4963_/A VGND VGND VPWR VPWR _4931_/A sky130_fd_sc_hd__and3_2
XTAP_TAPCELL_ROW_118_1728 VGND VPWR sky130_fd_sc_hd__tapvpwrvgnd_1
XFILLER_8_91 VGND VGND VPWR VPWR sky130_fd_sc_hd__decap_3
X_4636_ _4186_/A _4636_/B VGND VGND VPWR VPWR _4639_/A sky130_fd_sc_hd__and2b_2
XTAP_TAPCELL_ROW_118_1739 VGND VPWR sky130_fd_sc_hd__tapvpwrvgnd_1
X_7355_ _7355_/CLK _7355_/D _6635_/Y VGND VGND VPWR VPWR _7355_/Q sky130_fd_sc_hd__dfrtp_2
XFILLER_118_59 VGND VGND VPWR VPWR sky130_fd_sc_hd__decap_3
XFILLER_1_307 VGND VGND VPWR VPWR sky130_fd_sc_hd__decap_3
X_6306_ _6483_/A VGND VGND VPWR VPWR _6306_/Y sky130_fd_sc_hd__inv_2
X_4567_ _7297_/Q _4577_/B VGND VGND VPWR VPWR _7297_/D sky130_fd_sc_hd__and2_2
XFILLER_116_585 VGND VGND VPWR VPWR sky130_fd_sc_hd__decap_3
XFILLER_89_436 VGND VGND VPWR VPWR sky130_fd_sc_hd__decap_3
X_7286_ _7313_/CLK _7286_/D _6566_/Y VGND VGND VPWR VPWR _7286_/Q sky130_fd_sc_hd__dfrtp_2
Xhold687 _6864_/Q VGND VGND VPWR VPWR _6864_/D sky130_fd_sc_hd__dlygate4sd3_1
XFILLER_103_246 VGND VGND VPWR VPWR sky130_fd_sc_hd__decap_3
XFILLER_89_458 VGND VGND VPWR VPWR sky130_fd_sc_hd__decap_3
Xhold698 _6883_/Q VGND VGND VPWR VPWR _6883_/D sky130_fd_sc_hd__dlygate4sd3_1
X_3449_ _3449_/A _3449_/B _3449_/C VGND VGND VPWR VPWR _3449_/X sky130_fd_sc_hd__and3_2
XFILLER_85_620 VGND VGND VPWR VPWR sky130_fd_sc_hd__decap_3
XFILLER_97_480 VGND VGND VPWR VPWR sky130_fd_sc_hd__decap_3
XTAP_TAPCELL_ROW_90_1382 VGND VPWR sky130_fd_sc_hd__tapvpwrvgnd_1
XFILLER_111_290 VGND VGND VPWR VPWR sky130_fd_sc_hd__decap_3
XFILLER_84_130 VGND VGND VPWR VPWR sky130_fd_sc_hd__decap_3
XFILLER_85_653 VGND VGND VPWR VPWR sky130_fd_sc_hd__decap_3
Xhold1310 _7220_/Q VGND VGND VPWR VPWR _5217_/A sky130_fd_sc_hd__dlygate4sd3_1
Xhold1321 _7330_/Q VGND VGND VPWR VPWR _3956_/A1 sky130_fd_sc_hd__dlygate4sd3_1
X_5119_ _5670_/A _5670_/B _6984_/Q VGND VGND VPWR VPWR _5120_/B sky130_fd_sc_hd__a21oi_2
XFILLER_27_23 VGND VGND VPWR VPWR sky130_fd_sc_hd__decap_3
XFILLER_57_377 VGND VGND VPWR VPWR sky130_fd_sc_hd__decap_3
XFILLER_84_141 VGND VGND VPWR VPWR sky130_fd_sc_hd__decap_3
XFILLER_38_580 VGND VGND VPWR VPWR sky130_fd_sc_hd__fill_2
XFILLER_72_336 VGND VGND VPWR VPWR sky130_fd_sc_hd__decap_3
XFILLER_72_347 VGND VGND VPWR VPWR sky130_fd_sc_hd__decap_3
XFILLER_84_185 VGND VGND VPWR VPWR sky130_fd_sc_hd__decap_3
XFILLER_85_697 VGND VGND VPWR VPWR sky130_fd_sc_hd__decap_3
XFILLER_25_241 VGND VGND VPWR VPWR sky130_fd_sc_hd__decap_3
XFILLER_72_358 VGND VGND VPWR VPWR sky130_fd_sc_hd__decap_3
XFILLER_25_274 VGND VGND VPWR VPWR sky130_fd_sc_hd__decap_3
XFILLER_40_200 VGND VGND VPWR VPWR sky130_fd_sc_hd__decap_3
XFILLER_41_712 VGND VGND VPWR VPWR sky130_fd_sc_hd__fill_2
XFILLER_13_447 VGND VGND VPWR VPWR sky130_fd_sc_hd__fill_1
XFILLER_40_233 VGND VGND VPWR VPWR sky130_fd_sc_hd__decap_3
XFILLER_40_277 VGND VGND VPWR VPWR sky130_fd_sc_hd__decap_3
XFILLER_43_88 VGND VGND VPWR VPWR sky130_fd_sc_hd__fill_2
XFILLER_119_390 VGND VGND VPWR VPWR sky130_fd_sc_hd__fill_2
XFILLER_5_635 VGND VGND VPWR VPWR sky130_fd_sc_hd__decap_3
XFILLER_4_156 VGND VGND VPWR VPWR sky130_fd_sc_hd__fill_2
XFILLER_5_668 VGND VGND VPWR VPWR sky130_fd_sc_hd__decap_3
XFILLER_5_679 VGND VGND VPWR VPWR sky130_fd_sc_hd__decap_3
XFILLER_4_178 VGND VGND VPWR VPWR sky130_fd_sc_hd__fill_1
XFILLER_68_609 VGND VGND VPWR VPWR sky130_fd_sc_hd__decap_3
XFILLER_0_340 VGND VGND VPWR VPWR sky130_fd_sc_hd__decap_3
XFILLER_48_300 VGND VGND VPWR VPWR sky130_fd_sc_hd__decap_3
XFILLER_68_85 VGND VGND VPWR VPWR sky130_fd_sc_hd__decap_3
XFILLER_95_417 VGND VGND VPWR VPWR sky130_fd_sc_hd__decap_3
XFILLER_76_642 VGND VGND VPWR VPWR sky130_fd_sc_hd__fill_2
XFILLER_88_480 VGND VGND VPWR VPWR sky130_fd_sc_hd__decap_3
XFILLER_75_141 VGND VGND VPWR VPWR sky130_fd_sc_hd__decap_3
XFILLER_76_675 VGND VGND VPWR VPWR sky130_fd_sc_hd__decap_3
XFILLER_29_591 VGND VGND VPWR VPWR sky130_fd_sc_hd__decap_3
XFILLER_75_196 VGND VGND VPWR VPWR sky130_fd_sc_hd__decap_3
XFILLER_90_100 VGND VGND VPWR VPWR sky130_fd_sc_hd__fill_2
XFILLER_91_623 VGND VGND VPWR VPWR sky130_fd_sc_hd__decap_3
XFILLER_63_358 VGND VGND VPWR VPWR sky130_fd_sc_hd__decap_3
XFILLER_90_144 VGND VGND VPWR VPWR sky130_fd_sc_hd__decap_3
XFILLER_91_656 VGND VGND VPWR VPWR sky130_fd_sc_hd__decap_3
Xplace336 _3851_/A2 VGND VGND VPWR VPWR _3886_/A2 sky130_fd_sc_hd__buf_2
Xplace325 _3911_/B1 VGND VGND VPWR VPWR _3912_/B1 sky130_fd_sc_hd__buf_2
XFILLER_16_274 VGND VGND VPWR VPWR sky130_fd_sc_hd__decap_3
XFILLER_32_701 VGND VGND VPWR VPWR sky130_fd_sc_hd__decap_3
XFILLER_90_166 VGND VGND VPWR VPWR sky130_fd_sc_hd__fill_2
Xplace369 _4595_/B VGND VGND VPWR VPWR _4593_/B sky130_fd_sc_hd__buf_2
Xplace358 _3635_/B VGND VGND VPWR VPWR _5033_/B2 sky130_fd_sc_hd__buf_2
Xplace347 _3840_/A2 VGND VGND VPWR VPWR _3886_/B1 sky130_fd_sc_hd__buf_2
XFILLER_31_211 VGND VGND VPWR VPWR sky130_fd_sc_hd__fill_1
XTAP_TAPCELL_ROW_14_431 VGND VPWR sky130_fd_sc_hd__tapvpwrvgnd_1
XTAP_TAPCELL_ROW_102_1529 VGND VPWR sky130_fd_sc_hd__tapvpwrvgnd_1
XFILLER_31_266 VGND VGND VPWR VPWR sky130_fd_sc_hd__decap_3
XFILLER_12_480 VGND VGND VPWR VPWR sky130_fd_sc_hd__decap_3
XTAP_TAPCELL_ROW_42_784 VGND VPWR sky130_fd_sc_hd__tapvpwrvgnd_1
X_4421_ _7240_/Q _4421_/A2 _4421_/B1 _7176_/Q _4420_/X VGND VGND VPWR VPWR _4421_/X
+ sky130_fd_sc_hd__a221o_2
XFILLER_99_712 VGND VGND VPWR VPWR sky130_fd_sc_hd__fill_2
XFILLER_98_222 VGND VGND VPWR VPWR sky130_fd_sc_hd__decap_3
X_7140_ _7362_/CLK _7140_/D _6420_/Y VGND VGND VPWR VPWR _7140_/Q sky130_fd_sc_hd__dfrtp_2
X_4352_ _7289_/Q _5080_/S _4352_/B1 _7161_/Q _4351_/X VGND VGND VPWR VPWR _4352_/X
+ sky130_fd_sc_hd__a221o_2
XFILLER_101_706 VGND VGND VPWR VPWR sky130_fd_sc_hd__decap_3
XFILLER_4_690 VGND VGND VPWR VPWR sky130_fd_sc_hd__decap_3
X_7071_ _7390_/CLK _7071_/D _6351_/Y VGND VGND VPWR VPWR _7071_/Q sky130_fd_sc_hd__dfrtp_2
X_4283_ _7094_/Q _3417_/X _3407_/X _7126_/Q VGND VGND VPWR VPWR _4283_/X sky130_fd_sc_hd__a22o_2
X_3303_ _4467_/A _3519_/B _3302_/X VGND VGND VPWR VPWR _6981_/D sky130_fd_sc_hd__o21a_4
XTAP_TAPCELL_ROW_113_1669 VGND VPWR sky130_fd_sc_hd__tapvpwrvgnd_1
XFILLER_113_588 VGND VGND VPWR VPWR sky130_fd_sc_hd__decap_3
XFILLER_58_119 VGND VGND VPWR VPWR sky130_fd_sc_hd__decap_3
XFILLER_86_417 VGND VGND VPWR VPWR sky130_fd_sc_hd__decap_3
XFILLER_86_439 VGND VGND VPWR VPWR sky130_fd_sc_hd__decap_3
XFILLER_100_238 VGND VGND VPWR VPWR sky130_fd_sc_hd__fill_1
XFILLER_67_620 VGND VGND VPWR VPWR sky130_fd_sc_hd__decap_3
XFILLER_67_653 VGND VGND VPWR VPWR sky130_fd_sc_hd__decap_3
XFILLER_79_491 VGND VGND VPWR VPWR sky130_fd_sc_hd__decap_3
XFILLER_66_141 VGND VGND VPWR VPWR sky130_fd_sc_hd__decap_3
XTAP_TAPCELL_ROW_68_1104 VGND VPWR sky130_fd_sc_hd__tapvpwrvgnd_1
XFILLER_39_388 VGND VGND VPWR VPWR sky130_fd_sc_hd__decap_3
XFILLER_39_399 VGND VGND VPWR VPWR sky130_fd_sc_hd__fill_1
XFILLER_66_185 VGND VGND VPWR VPWR sky130_fd_sc_hd__decap_3
XFILLER_67_697 VGND VGND VPWR VPWR sky130_fd_sc_hd__decap_3
XFILLER_81_122 VGND VGND VPWR VPWR sky130_fd_sc_hd__decap_3
XFILLER_82_634 VGND VGND VPWR VPWR sky130_fd_sc_hd__decap_3
XFILLER_82_645 VGND VGND VPWR VPWR sky130_fd_sc_hd__decap_3
XFILLER_35_550 VGND VGND VPWR VPWR sky130_fd_sc_hd__fill_2
XFILLER_81_155 VGND VGND VPWR VPWR sky130_fd_sc_hd__decap_3
XFILLER_82_678 VGND VGND VPWR VPWR sky130_fd_sc_hd__decap_3
X_6924_ _6944_/CLK _6924_/D VGND VGND VPWR VPWR _6924_/Q sky130_fd_sc_hd__dfxtp_2
XFILLER_22_200 VGND VGND VPWR VPWR sky130_fd_sc_hd__fill_2
XFILLER_23_712 VGND VGND VPWR VPWR sky130_fd_sc_hd__fill_2
XFILLER_35_594 VGND VGND VPWR VPWR sky130_fd_sc_hd__decap_3
X_6855_ clkload8/A _6855_/D VGND VGND VPWR VPWR _6855_/Q sky130_fd_sc_hd__dfxtp_2
XFILLER_22_277 VGND VGND VPWR VPWR sky130_fd_sc_hd__decap_3
X_6786_ _6922_/CLK _6786_/D VGND VGND VPWR VPWR _6786_/Q sky130_fd_sc_hd__dfxtp_2
X_5737_ _7374_/Q _5737_/A1 _5737_/S VGND VGND VPWR VPWR _6718_/D sky130_fd_sc_hd__mux2_2
XFILLER_13_69 VGND VGND VPWR VPWR sky130_fd_sc_hd__fill_2
XFILLER_108_349 VGND VGND VPWR VPWR sky130_fd_sc_hd__decap_3
X_5668_ _5668_/A _5668_/B VGND VGND VPWR VPWR _6980_/D sky130_fd_sc_hd__or2_2
XTAP_TAPCELL_ROW_79_1244 VGND VPWR sky130_fd_sc_hd__tapvpwrvgnd_1
X_4619_ _4619_/A _4619_/B _5101_/B _5073_/A VGND VGND VPWR VPWR _4619_/Y sky130_fd_sc_hd__nor4_1
XTAP_TAPCELL_ROW_92_1411 VGND VPWR sky130_fd_sc_hd__tapvpwrvgnd_1
XFILLER_2_616 VGND VGND VPWR VPWR sky130_fd_sc_hd__decap_3
XFILLER_89_211 VGND VGND VPWR VPWR sky130_fd_sc_hd__decap_3
X_7338_ _7342_/CLK _7338_/D _6618_/Y VGND VGND VPWR VPWR _7338_/Q sky130_fd_sc_hd__dfrtp_2
XFILLER_104_533 VGND VGND VPWR VPWR sky130_fd_sc_hd__decap_3
X_7269_ _7400_/CLK _7269_/D _6549_/Y VGND VGND VPWR VPWR _7269_/Q sky130_fd_sc_hd__dfrtp_2
XFILLER_77_417 VGND VGND VPWR VPWR sky130_fd_sc_hd__decap_3
XFILLER_89_277 VGND VGND VPWR VPWR sky130_fd_sc_hd__decap_3
XFILLER_38_44 VGND VGND VPWR VPWR sky130_fd_sc_hd__fill_2
XFILLER_58_631 VGND VGND VPWR VPWR sky130_fd_sc_hd__decap_3
XFILLER_38_66 VGND VGND VPWR VPWR sky130_fd_sc_hd__fill_2
XFILLER_58_675 VGND VGND VPWR VPWR sky130_fd_sc_hd__decap_3
XFILLER_85_461 VGND VGND VPWR VPWR sky130_fd_sc_hd__decap_3
Xhold1140 _7257_/Q VGND VGND VPWR VPWR _5080_/A0 sky130_fd_sc_hd__dlygate4sd3_1
Xhold1151 _7319_/Q VGND VGND VPWR VPWR _4520_/A0 sky130_fd_sc_hd__dlygate4sd3_1
XFILLER_45_325 VGND VGND VPWR VPWR sky130_fd_sc_hd__decap_3
XFILLER_57_163 VGND VGND VPWR VPWR sky130_fd_sc_hd__decap_3
XFILLER_57_185 VGND VGND VPWR VPWR sky130_fd_sc_hd__decap_3
XFILLER_73_623 VGND VGND VPWR VPWR sky130_fd_sc_hd__decap_3
Xhold1162 _7222_/Q VGND VGND VPWR VPWR _5213_/A sky130_fd_sc_hd__dlygate4sd3_1
Xhold1173 _7331_/Q VGND VGND VPWR VPWR _4497_/A0 sky130_fd_sc_hd__dlygate4sd3_1
Xhold1184 _7246_/Q VGND VGND VPWR VPWR _5163_/A sky130_fd_sc_hd__dlygate4sd3_1
XFILLER_45_358 VGND VGND VPWR VPWR sky130_fd_sc_hd__decap_3
XFILLER_72_144 VGND VGND VPWR VPWR sky130_fd_sc_hd__decap_3
XFILLER_73_656 VGND VGND VPWR VPWR sky130_fd_sc_hd__decap_3
Xhold1195 _7132_/Q VGND VGND VPWR VPWR _5402_/A0 sky130_fd_sc_hd__dlygate4sd3_1
XFILLER_14_701 VGND VGND VPWR VPWR sky130_fd_sc_hd__decap_3
XFILLER_26_572 VGND VGND VPWR VPWR sky130_fd_sc_hd__decap_3
XFILLER_72_177 VGND VGND VPWR VPWR sky130_fd_sc_hd__decap_3
XFILLER_41_531 VGND VGND VPWR VPWR sky130_fd_sc_hd__decap_3
XFILLER_110_71 VGND VGND VPWR VPWR sky130_fd_sc_hd__decap_3
XFILLER_13_255 VGND VGND VPWR VPWR sky130_fd_sc_hd__fill_1
XFILLER_41_553 VGND VGND VPWR VPWR sky130_fd_sc_hd__decap_3
XFILLER_41_597 VGND VGND VPWR VPWR sky130_fd_sc_hd__decap_3
XTAP_TAPCELL_ROW_11_401 VGND VPWR sky130_fd_sc_hd__tapvpwrvgnd_1
XFILLER_70_75 VGND VGND VPWR VPWR sky130_fd_sc_hd__fill_1
XFILLER_70_97 VGND VGND VPWR VPWR sky130_fd_sc_hd__decap_3
Xclkload18 _7357_/CLK VGND VGND VPWR VPWR clkload18/Y sky130_fd_sc_hd__bufinv_16
Xclkload29 _7400_/CLK VGND VGND VPWR VPWR clkload29/Y sky130_fd_sc_hd__inv_6
XFILLER_107_382 VGND VGND VPWR VPWR sky130_fd_sc_hd__decap_3
XFILLER_5_476 VGND VGND VPWR VPWR sky130_fd_sc_hd__decap_3
XFILLER_79_84 VGND VGND VPWR VPWR sky130_fd_sc_hd__decap_3
XFILLER_96_704 VGND VGND VPWR VPWR sky130_fd_sc_hd__decap_3
XFILLER_1_671 VGND VGND VPWR VPWR sky130_fd_sc_hd__fill_1
XFILLER_95_203 VGND VGND VPWR VPWR sky130_fd_sc_hd__fill_1
XFILLER_110_536 VGND VGND VPWR VPWR sky130_fd_sc_hd__decap_3
XFILLER_1_682 VGND VGND VPWR VPWR sky130_fd_sc_hd__decap_3
XFILLER_49_620 VGND VGND VPWR VPWR sky130_fd_sc_hd__decap_3
XFILLER_68_439 VGND VGND VPWR VPWR sky130_fd_sc_hd__decap_3
XFILLER_48_130 VGND VGND VPWR VPWR sky130_fd_sc_hd__decap_3
XFILLER_48_141 VGND VGND VPWR VPWR sky130_fd_sc_hd__decap_3
XFILLER_49_653 VGND VGND VPWR VPWR sky130_fd_sc_hd__decap_3
XFILLER_64_601 VGND VGND VPWR VPWR sky130_fd_sc_hd__decap_3
XFILLER_76_450 VGND VGND VPWR VPWR sky130_fd_sc_hd__decap_3
XFILLER_95_72 VGND VGND VPWR VPWR sky130_fd_sc_hd__decap_3
XFILLER_48_163 VGND VGND VPWR VPWR sky130_fd_sc_hd__decap_3
XFILLER_49_697 VGND VGND VPWR VPWR sky130_fd_sc_hd__decap_3
XFILLER_63_111 VGND VGND VPWR VPWR sky130_fd_sc_hd__fill_1
XFILLER_64_634 VGND VGND VPWR VPWR sky130_fd_sc_hd__decap_3
XFILLER_64_645 VGND VGND VPWR VPWR sky130_fd_sc_hd__decap_3
XFILLER_76_483 VGND VGND VPWR VPWR sky130_fd_sc_hd__decap_3
XTAP_TAPCELL_ROW_19_501 VGND VPWR sky130_fd_sc_hd__tapvpwrvgnd_1
XFILLER_36_358 VGND VGND VPWR VPWR sky130_fd_sc_hd__decap_3
XFILLER_63_122 VGND VGND VPWR VPWR sky130_fd_sc_hd__decap_3
XFILLER_64_678 VGND VGND VPWR VPWR sky130_fd_sc_hd__decap_3
Xplace111 _3665_/B VGND VGND VPWR VPWR place111/X sky130_fd_sc_hd__buf_2
XTAP_TAPCELL_ROW_47_843 VGND VPWR sky130_fd_sc_hd__tapvpwrvgnd_1
XFILLER_17_572 VGND VGND VPWR VPWR sky130_fd_sc_hd__decap_3
XFILLER_63_166 VGND VGND VPWR VPWR sky130_fd_sc_hd__fill_2
XFILLER_91_486 VGND VGND VPWR VPWR sky130_fd_sc_hd__decap_3
X_4970_ _4970_/A1 _4950_/B _4967_/B _5033_/B2 VGND VGND VPWR VPWR _4970_/X sky130_fd_sc_hd__a22o_2
XFILLER_32_542 VGND VGND VPWR VPWR sky130_fd_sc_hd__decap_3
XFILLER_44_380 VGND VGND VPWR VPWR sky130_fd_sc_hd__fill_1
X_3921_ _6914_/Q _3921_/A2 _3925_/A2 _6688_/Q VGND VGND VPWR VPWR _3921_/X sky130_fd_sc_hd__a22o_2
XFILLER_20_704 VGND VGND VPWR VPWR sky130_fd_sc_hd__decap_3
X_6640_ _6640_/A VGND VGND VPWR VPWR _6640_/Y sky130_fd_sc_hd__inv_2
X_3852_ _6748_/Q _3661_/X _3665_/X _6742_/Q VGND VGND VPWR VPWR _3852_/X sky130_fd_sc_hd__a22o_2
XTAP_TAPCELL_ROW_63_1045 VGND VPWR sky130_fd_sc_hd__tapvpwrvgnd_1
X_6571_ _6571_/A VGND VGND VPWR VPWR _6571_/Y sky130_fd_sc_hd__inv_2
XFILLER_118_625 VGND VGND VPWR VPWR sky130_fd_sc_hd__decap_3
X_3783_ _6812_/Q _3656_/Y _3850_/B1 _6822_/Q _3782_/X VGND VGND VPWR VPWR _3783_/X
+ sky130_fd_sc_hd__a221o_2
XFILLER_117_102 VGND VGND VPWR VPWR sky130_fd_sc_hd__decap_3
XFILLER_8_270 VGND VGND VPWR VPWR sky130_fd_sc_hd__fill_1
XFILLER_117_146 VGND VGND VPWR VPWR sky130_fd_sc_hd__decap_3
XFILLER_118_669 VGND VGND VPWR VPWR sky130_fd_sc_hd__decap_3
XFILLER_105_319 VGND VGND VPWR VPWR sky130_fd_sc_hd__decap_3
X_4404_ _7306_/Q _4914_/S _4434_/A2 _7114_/Q VGND VGND VPWR VPWR _4404_/X sky130_fd_sc_hd__a22o_2
XFILLER_99_520 VGND VGND VPWR VPWR sky130_fd_sc_hd__fill_1
X_7123_ _7345_/CLK _7123_/D _6403_/Y VGND VGND VPWR VPWR _7123_/Q sky130_fd_sc_hd__dfrtp_2
Xoutput578 _5657_/D VGND VGND VPWR VPWR alu_result_out[15] sky130_fd_sc_hd__clkdlybuf4s25_1
X_4335_ _7287_/Q _4335_/A2 _4351_/A2 _7095_/Q VGND VGND VPWR VPWR _4336_/C sky130_fd_sc_hd__a22o_2
XFILLER_99_564 VGND VGND VPWR VPWR sky130_fd_sc_hd__decap_3
XFILLER_101_503 VGND VGND VPWR VPWR sky130_fd_sc_hd__fill_1
XFILLER_113_352 VGND VGND VPWR VPWR sky130_fd_sc_hd__fill_1
XFILLER_115_27 VGND VGND VPWR VPWR sky130_fd_sc_hd__decap_3
XFILLER_59_417 VGND VGND VPWR VPWR sky130_fd_sc_hd__decap_3
XFILLER_5_92 VGND VGND VPWR VPWR sky130_fd_sc_hd__decap_3
Xoutput589 _5663_/B VGND VGND VPWR VPWR alu_result_out[25] sky130_fd_sc_hd__clkdlybuf4s25_1
XTAP_TAPCELL_ROW_74_1185 VGND VPWR sky130_fd_sc_hd__tapvpwrvgnd_1
XFILLER_101_536 VGND VGND VPWR VPWR sky130_fd_sc_hd__fill_2
XFILLER_113_396 VGND VGND VPWR VPWR sky130_fd_sc_hd__fill_2
XFILLER_86_236 VGND VGND VPWR VPWR sky130_fd_sc_hd__decap_3
X_7054_ _7372_/CLK _7054_/D _6334_/Y VGND VGND VPWR VPWR _7054_/Q sky130_fd_sc_hd__dfrtp_2
X_4266_ _7294_/Q _5080_/S _4351_/A2 _7102_/Q VGND VGND VPWR VPWR _4271_/A sky130_fd_sc_hd__a22o_2
XFILLER_101_569 VGND VGND VPWR VPWR sky130_fd_sc_hd__decap_3
X_4197_ _7199_/Q _3964_/S _4269_/B1 _7044_/Q _4196_/X VGND VGND VPWR VPWR _4197_/X
+ sky130_fd_sc_hd__a221o_2
XFILLER_27_303 VGND VGND VPWR VPWR sky130_fd_sc_hd__decap_3
XFILLER_54_111 VGND VGND VPWR VPWR sky130_fd_sc_hd__decap_3
XFILLER_55_612 VGND VGND VPWR VPWR sky130_fd_sc_hd__decap_3
XFILLER_55_623 VGND VGND VPWR VPWR sky130_fd_sc_hd__decap_3
XFILLER_27_358 VGND VGND VPWR VPWR sky130_fd_sc_hd__decap_3
XFILLER_54_144 VGND VGND VPWR VPWR sky130_fd_sc_hd__decap_3
XFILLER_55_656 VGND VGND VPWR VPWR sky130_fd_sc_hd__decap_3
XFILLER_54_177 VGND VGND VPWR VPWR sky130_fd_sc_hd__decap_3
XFILLER_70_604 VGND VGND VPWR VPWR sky130_fd_sc_hd__decap_3
XFILLER_70_637 VGND VGND VPWR VPWR sky130_fd_sc_hd__decap_3
XFILLER_82_486 VGND VGND VPWR VPWR sky130_fd_sc_hd__decap_3
XFILLER_23_520 VGND VGND VPWR VPWR sky130_fd_sc_hd__fill_1
XFILLER_70_648 VGND VGND VPWR VPWR sky130_fd_sc_hd__decap_3
X_6907_ _7189_/CLK _6907_/D VGND VGND VPWR VPWR _6907_/Q sky130_fd_sc_hd__dfxtp_2
X_6838_ clkload6/A _6838_/D VGND VGND VPWR VPWR _6838_/Q sky130_fd_sc_hd__dfxtp_2
XFILLER_10_203 VGND VGND VPWR VPWR sky130_fd_sc_hd__decap_3
XFILLER_23_597 VGND VGND VPWR VPWR sky130_fd_sc_hd__decap_3
XFILLER_109_614 VGND VGND VPWR VPWR sky130_fd_sc_hd__fill_2
X_6769_ _6968_/CLK _6769_/D VGND VGND VPWR VPWR _6769_/Q sky130_fd_sc_hd__dfxtp_2
XFILLER_108_102 VGND VGND VPWR VPWR sky130_fd_sc_hd__fill_1
XFILLER_109_647 VGND VGND VPWR VPWR sky130_fd_sc_hd__decap_3
XFILLER_104_330 VGND VGND VPWR VPWR sky130_fd_sc_hd__decap_3
XFILLER_117_691 VGND VGND VPWR VPWR sky130_fd_sc_hd__decap_3
XFILLER_78_704 VGND VGND VPWR VPWR sky130_fd_sc_hd__decap_3
XFILLER_104_363 VGND VGND VPWR VPWR sky130_fd_sc_hd__fill_1
XFILLER_104_374 VGND VGND VPWR VPWR sky130_fd_sc_hd__decap_3
XFILLER_2_468 VGND VGND VPWR VPWR sky130_fd_sc_hd__fill_1
XFILLER_49_43 VGND VGND VPWR VPWR sky130_fd_sc_hd__fill_1
XFILLER_77_225 VGND VGND VPWR VPWR sky130_fd_sc_hd__decap_3
XFILLER_105_60 VGND VGND VPWR VPWR sky130_fd_sc_hd__fill_2
XFILLER_46_601 VGND VGND VPWR VPWR sky130_fd_sc_hd__decap_3
XFILLER_100_580 VGND VGND VPWR VPWR sky130_fd_sc_hd__decap_3
XFILLER_105_71 VGND VGND VPWR VPWR sky130_fd_sc_hd__decap_3
XFILLER_46_634 VGND VGND VPWR VPWR sky130_fd_sc_hd__decap_3
XFILLER_58_472 VGND VGND VPWR VPWR sky130_fd_sc_hd__decap_3
XFILLER_58_494 VGND VGND VPWR VPWR sky130_fd_sc_hd__fill_1
XFILLER_46_645 VGND VGND VPWR VPWR sky130_fd_sc_hd__decap_3
XFILLER_73_442 VGND VGND VPWR VPWR sky130_fd_sc_hd__decap_3
XFILLER_33_317 VGND VGND VPWR VPWR sky130_fd_sc_hd__decap_3
XFILLER_45_177 VGND VGND VPWR VPWR sky130_fd_sc_hd__decap_3
XFILLER_46_678 VGND VGND VPWR VPWR sky130_fd_sc_hd__decap_3
XFILLER_61_626 VGND VGND VPWR VPWR sky130_fd_sc_hd__decap_3
XFILLER_65_97 VGND VGND VPWR VPWR sky130_fd_sc_hd__fill_1
XTAP_TAPCELL_ROW_44_813 VGND VPWR sky130_fd_sc_hd__tapvpwrvgnd_1
XTAP_TAPCELL_ROW_44_802 VGND VPWR sky130_fd_sc_hd__tapvpwrvgnd_1
XFILLER_60_114 VGND VGND VPWR VPWR sky130_fd_sc_hd__fill_1
XFILLER_60_125 VGND VGND VPWR VPWR sky130_fd_sc_hd__decap_3
XFILLER_61_659 VGND VGND VPWR VPWR sky130_fd_sc_hd__decap_3
XFILLER_73_497 VGND VGND VPWR VPWR sky130_fd_sc_hd__decap_3
XFILLER_60_147 VGND VGND VPWR VPWR sky130_fd_sc_hd__decap_3
XFILLER_81_52 VGND VGND VPWR VPWR sky130_fd_sc_hd__decap_3
XFILLER_81_63 VGND VGND VPWR VPWR sky130_fd_sc_hd__decap_3
XFILLER_115_617 VGND VGND VPWR VPWR sky130_fd_sc_hd__decap_3
XPHY_EDGE_ROW_116_Right_116 VGND VGND VPWR VPWR sky130_fd_sc_hd__decap_3
XFILLER_53_6 VGND VGND VPWR VPWR sky130_fd_sc_hd__decap_3
XFILLER_5_251 VGND VGND VPWR VPWR sky130_fd_sc_hd__decap_3
XFILLER_107_190 VGND VGND VPWR VPWR sky130_fd_sc_hd__decap_3
XFILLER_114_138 VGND VGND VPWR VPWR sky130_fd_sc_hd__fill_2
XFILLER_5_284 VGND VGND VPWR VPWR sky130_fd_sc_hd__decap_3
XTAP_TAPCELL_ROW_110_1639 VGND VPWR sky130_fd_sc_hd__tapvpwrvgnd_1
XTAP_TAPCELL_ROW_110_1628 VGND VPWR sky130_fd_sc_hd__tapvpwrvgnd_1
XFILLER_68_247 VGND VGND VPWR VPWR sky130_fd_sc_hd__decap_3
X_4120_ _7300_/Q _5080_/S _4417_/B1 _7108_/Q VGND VGND VPWR VPWR _4120_/X sky130_fd_sc_hd__a22o_2
XFILLER_1_490 VGND VGND VPWR VPWR sky130_fd_sc_hd__decap_3
XFILLER_84_707 VGND VGND VPWR VPWR sky130_fd_sc_hd__decap_3
XFILLER_37_623 VGND VGND VPWR VPWR sky130_fd_sc_hd__decap_3
XFILLER_83_217 VGND VGND VPWR VPWR sky130_fd_sc_hd__decap_3
XFILLER_83_228 VGND VGND VPWR VPWR sky130_fd_sc_hd__decap_3
XFILLER_36_144 VGND VGND VPWR VPWR sky130_fd_sc_hd__decap_3
XFILLER_37_656 VGND VGND VPWR VPWR sky130_fd_sc_hd__decap_3
XFILLER_64_453 VGND VGND VPWR VPWR sky130_fd_sc_hd__fill_2
XFILLER_76_280 VGND VGND VPWR VPWR sky130_fd_sc_hd__fill_2
XFILLER_24_306 VGND VGND VPWR VPWR sky130_fd_sc_hd__fill_2
XFILLER_64_486 VGND VGND VPWR VPWR sky130_fd_sc_hd__decap_3
XFILLER_52_637 VGND VGND VPWR VPWR sky130_fd_sc_hd__decap_3
XFILLER_52_648 VGND VGND VPWR VPWR sky130_fd_sc_hd__decap_3
XFILLER_91_294 VGND VGND VPWR VPWR sky130_fd_sc_hd__decap_3
X_4953_ _4200_/A _4381_/A _4969_/C _4814_/A VGND VGND VPWR VPWR _4953_/Y sky130_fd_sc_hd__a31oi_2
XFILLER_51_169 VGND VGND VPWR VPWR sky130_fd_sc_hd__decap_3
X_3904_ _5151_/A _3904_/B VGND VGND VPWR VPWR _3904_/Y sky130_fd_sc_hd__nand2_2
XFILLER_20_501 VGND VGND VPWR VPWR sky130_fd_sc_hd__decap_3
XFILLER_60_681 VGND VGND VPWR VPWR sky130_fd_sc_hd__decap_3
X_6623_ _6625_/A VGND VGND VPWR VPWR _6623_/Y sky130_fd_sc_hd__inv_2
X_4884_ _4884_/A _4904_/B VGND VGND VPWR VPWR _4884_/X sky130_fd_sc_hd__or2_2
XTAP_TAPCELL_ROW_22_529 VGND VPWR sky130_fd_sc_hd__tapvpwrvgnd_1
XFILLER_20_556 VGND VGND VPWR VPWR sky130_fd_sc_hd__decap_3
X_3835_ _6725_/Q _3661_/X _3840_/A2 _6975_/Q VGND VGND VPWR VPWR _3835_/X sky130_fd_sc_hd__a22o_2
XFILLER_20_589 VGND VGND VPWR VPWR sky130_fd_sc_hd__decap_3
X_6554_ _6554_/A VGND VGND VPWR VPWR _6554_/Y sky130_fd_sc_hd__inv_2
X_3766_ _3766_/A1 _3857_/A2 _4927_/B VGND VGND VPWR VPWR _7394_/D sky130_fd_sc_hd__a21o_2
XFILLER_118_444 VGND VGND VPWR VPWR sky130_fd_sc_hd__decap_3
XFILLER_118_455 VGND VGND VPWR VPWR sky130_fd_sc_hd__decap_3
X_6485_ _6680_/A VGND VGND VPWR VPWR _6485_/Y sky130_fd_sc_hd__inv_2
XTAP_TAPCELL_ROW_76_1214 VGND VPWR sky130_fd_sc_hd__tapvpwrvgnd_1
XTAP_TAPCELL_ROW_76_1203 VGND VPWR sky130_fd_sc_hd__tapvpwrvgnd_1
XFILLER_105_105 VGND VGND VPWR VPWR sky130_fd_sc_hd__decap_3
XFILLER_105_116 VGND VGND VPWR VPWR sky130_fd_sc_hd__decap_3
XFILLER_106_628 VGND VGND VPWR VPWR sky130_fd_sc_hd__decap_3
XFILLER_118_477 VGND VGND VPWR VPWR sky130_fd_sc_hd__fill_2
X_3697_ _3682_/A _3696_/X _4791_/A1 VGND VGND VPWR VPWR _3697_/Y sky130_fd_sc_hd__a21oi_2
XFILLER_105_138 VGND VGND VPWR VPWR sky130_fd_sc_hd__decap_3
XFILLER_114_672 VGND VGND VPWR VPWR sky130_fd_sc_hd__decap_3
X_5367_ _5367_/A0 _4734_/X _5379_/S VGND VGND VPWR VPWR _7149_/D sky130_fd_sc_hd__mux2_2
XFILLER_113_160 VGND VGND VPWR VPWR sky130_fd_sc_hd__decap_3
XFILLER_59_225 VGND VGND VPWR VPWR sky130_fd_sc_hd__fill_1
XFILLER_87_523 VGND VGND VPWR VPWR sky130_fd_sc_hd__decap_3
X_7106_ _7370_/CLK _7106_/D _6386_/Y VGND VGND VPWR VPWR _7106_/Q sky130_fd_sc_hd__dfrtp_2
X_5298_ _5298_/A0 _4734_/X _5315_/S VGND VGND VPWR VPWR _7181_/D sky130_fd_sc_hd__mux2_2
X_4318_ _7290_/Q _4419_/A2 _4339_/B1 _7162_/Q _4317_/X VGND VGND VPWR VPWR _4318_/X
+ sky130_fd_sc_hd__a221o_2
XFILLER_101_333 VGND VGND VPWR VPWR sky130_fd_sc_hd__decap_3
XFILLER_101_355 VGND VGND VPWR VPWR sky130_fd_sc_hd__decap_3
XFILLER_19_46 VGND VGND VPWR VPWR sky130_fd_sc_hd__fill_1
XFILLER_59_269 VGND VGND VPWR VPWR sky130_fd_sc_hd__decap_3
XFILLER_87_556 VGND VGND VPWR VPWR sky130_fd_sc_hd__decap_3
X_7037_ _7354_/CLK _7037_/D _6317_/Y VGND VGND VPWR VPWR _7037_/Q sky130_fd_sc_hd__dfrtp_2
X_4249_ _7069_/Q _4265_/B _4205_/A VGND VGND VPWR VPWR _4626_/C sky130_fd_sc_hd__o21a_2
XFILLER_101_399 VGND VGND VPWR VPWR sky130_fd_sc_hd__fill_1
XFILLER_28_601 VGND VGND VPWR VPWR sky130_fd_sc_hd__decap_3
XFILLER_28_634 VGND VGND VPWR VPWR sky130_fd_sc_hd__decap_3
XFILLER_74_206 VGND VGND VPWR VPWR sky130_fd_sc_hd__decap_3
XFILLER_74_228 VGND VGND VPWR VPWR sky130_fd_sc_hd__decap_3
XFILLER_28_645 VGND VGND VPWR VPWR sky130_fd_sc_hd__decap_3
XTAP_TAPCELL_ROW_87_1343 VGND VPWR sky130_fd_sc_hd__tapvpwrvgnd_1
XFILLER_15_317 VGND VGND VPWR VPWR sky130_fd_sc_hd__decap_3
XFILLER_28_678 VGND VGND VPWR VPWR sky130_fd_sc_hd__decap_3
XFILLER_43_615 VGND VGND VPWR VPWR sky130_fd_sc_hd__fill_1
XFILLER_43_626 VGND VGND VPWR VPWR sky130_fd_sc_hd__decap_3
XFILLER_55_475 VGND VGND VPWR VPWR sky130_fd_sc_hd__decap_3
XFILLER_70_412 VGND VGND VPWR VPWR sky130_fd_sc_hd__fill_1
XTAP_TAPCELL_ROW_2_287 VGND VPWR sky130_fd_sc_hd__tapvpwrvgnd_1
XFILLER_42_125 VGND VGND VPWR VPWR sky130_fd_sc_hd__decap_3
XFILLER_43_659 VGND VGND VPWR VPWR sky130_fd_sc_hd__decap_3
XFILLER_42_158 VGND VGND VPWR VPWR sky130_fd_sc_hd__decap_3
XFILLER_11_501 VGND VGND VPWR VPWR sky130_fd_sc_hd__decap_3
XFILLER_11_556 VGND VGND VPWR VPWR sky130_fd_sc_hd__decap_3
XFILLER_11_567 VGND VGND VPWR VPWR sky130_fd_sc_hd__decap_3
XFILLER_50_191 VGND VGND VPWR VPWR sky130_fd_sc_hd__decap_3
XFILLER_7_505 VGND VGND VPWR VPWR sky130_fd_sc_hd__decap_3
XFILLER_51_99 VGND VGND VPWR VPWR sky130_fd_sc_hd__decap_3
XTAP_TAPCELL_ROW_98_1483 VGND VPWR sky130_fd_sc_hd__tapvpwrvgnd_1
XFILLER_3_700 VGND VGND VPWR VPWR sky130_fd_sc_hd__decap_3
XFILLER_105_650 VGND VGND VPWR VPWR sky130_fd_sc_hd__decap_3
XFILLER_104_171 VGND VGND VPWR VPWR sky130_fd_sc_hd__decap_3
XFILLER_105_694 VGND VGND VPWR VPWR sky130_fd_sc_hd__decap_3
XFILLER_78_523 VGND VGND VPWR VPWR sky130_fd_sc_hd__decap_3
XFILLER_78_545 VGND VGND VPWR VPWR sky130_fd_sc_hd__decap_3
XFILLER_66_707 VGND VGND VPWR VPWR sky130_fd_sc_hd__decap_3
XFILLER_18_100 VGND VGND VPWR VPWR sky130_fd_sc_hd__decap_3
XFILLER_19_601 VGND VGND VPWR VPWR sky130_fd_sc_hd__decap_3
XFILLER_19_623 VGND VGND VPWR VPWR sky130_fd_sc_hd__decap_3
XFILLER_65_206 VGND VGND VPWR VPWR sky130_fd_sc_hd__decap_3
XFILLER_76_85 VGND VGND VPWR VPWR sky130_fd_sc_hd__decap_3
XFILLER_78_589 VGND VGND VPWR VPWR sky130_fd_sc_hd__fill_1
Xsingle_cycle_cpu_679 VGND VGND VPWR VPWR single_cycle_cpu_679/HI instruction_out[31]
+ sky130_fd_sc_hd__conb_1
XFILLER_19_656 VGND VGND VPWR VPWR sky130_fd_sc_hd__decap_3
XFILLER_58_291 VGND VGND VPWR VPWR sky130_fd_sc_hd__decap_3
XFILLER_34_604 VGND VGND VPWR VPWR sky130_fd_sc_hd__decap_3
XFILLER_46_453 VGND VGND VPWR VPWR sky130_fd_sc_hd__decap_3
XFILLER_46_486 VGND VGND VPWR VPWR sky130_fd_sc_hd__decap_3
XTAP_TAPCELL_ROW_57_971 VGND VPWR sky130_fd_sc_hd__tapvpwrvgnd_1
XFILLER_34_637 VGND VGND VPWR VPWR sky130_fd_sc_hd__decap_3
XFILLER_34_648 VGND VGND VPWR VPWR sky130_fd_sc_hd__decap_3
XFILLER_61_445 VGND VGND VPWR VPWR sky130_fd_sc_hd__decap_3
XFILLER_73_272 VGND VGND VPWR VPWR sky130_fd_sc_hd__decap_3
XFILLER_33_169 VGND VGND VPWR VPWR sky130_fd_sc_hd__decap_3
XTAP_TAPCELL_ROW_107_1590 VGND VPWR sky130_fd_sc_hd__tapvpwrvgnd_1
XFILLER_42_681 VGND VGND VPWR VPWR sky130_fd_sc_hd__decap_3
XFILLER_61_489 VGND VGND VPWR VPWR sky130_fd_sc_hd__decap_3
XTAP_TAPCELL_ROW_60_1004 VGND VPWR sky130_fd_sc_hd__tapvpwrvgnd_1
XFILLER_119_219 VGND VGND VPWR VPWR sky130_fd_sc_hd__decap_3
X_3620_ _3620_/A _4292_/B _3620_/C VGND VGND VPWR VPWR _3620_/X sky130_fd_sc_hd__or3_4
X_3551_ _3508_/A _3547_/Y _3550_/X VGND VGND VPWR VPWR _3551_/X sky130_fd_sc_hd__a21o_2
XFILLER_115_403 VGND VGND VPWR VPWR sky130_fd_sc_hd__decap_3
XFILLER_115_425 VGND VGND VPWR VPWR sky130_fd_sc_hd__decap_3
XFILLER_6_560 VGND VGND VPWR VPWR sky130_fd_sc_hd__decap_3
XFILLER_115_436 VGND VGND VPWR VPWR sky130_fd_sc_hd__fill_2
XFILLER_115_447 VGND VGND VPWR VPWR sky130_fd_sc_hd__fill_1
XFILLER_51_3 VGND VGND VPWR VPWR sky130_fd_sc_hd__fill_1
X_6270_ _6678_/A VGND VGND VPWR VPWR _6270_/Y sky130_fd_sc_hd__inv_2
X_3482_ _3482_/A _3482_/B _3482_/C VGND VGND VPWR VPWR _3482_/Y sky130_fd_sc_hd__nor3_2
XFILLER_103_609 VGND VGND VPWR VPWR sky130_fd_sc_hd__decap_3
XFILLER_88_309 VGND VGND VPWR VPWR sky130_fd_sc_hd__decap_3
X_5221_ _5221_/A _5225_/B VGND VGND VPWR VPWR _7218_/D sky130_fd_sc_hd__and2_2
XFILLER_111_620 VGND VGND VPWR VPWR sky130_fd_sc_hd__decap_3
X_5152_ _7009_/Q _5152_/B VGND VGND VPWR VPWR _5152_/Y sky130_fd_sc_hd__nand2_2
XTAP_TAPCELL_ROW_71_1144 VGND VPWR sky130_fd_sc_hd__tapvpwrvgnd_1
XFILLER_110_130 VGND VGND VPWR VPWR sky130_fd_sc_hd__decap_3
XFILLER_110_141 VGND VGND VPWR VPWR sky130_fd_sc_hd__fill_1
XFILLER_111_653 VGND VGND VPWR VPWR sky130_fd_sc_hd__decap_3
X_4103_ _7365_/Q _4416_/A2 _4267_/B1 _7173_/Q VGND VGND VPWR VPWR _4103_/X sky130_fd_sc_hd__a22o_2
XFILLER_110_163 VGND VGND VPWR VPWR sky130_fd_sc_hd__decap_3
XFILLER_110_174 VGND VGND VPWR VPWR sky130_fd_sc_hd__fill_2
XFILLER_111_697 VGND VGND VPWR VPWR sky130_fd_sc_hd__decap_3
XFILLER_96_386 VGND VGND VPWR VPWR sky130_fd_sc_hd__fill_1
X_5083_ _5086_/A _4343_/X VGND VGND VPWR VPWR _5083_/X sky130_fd_sc_hd__or2b_2
XFILLER_37_420 VGND VGND VPWR VPWR sky130_fd_sc_hd__decap_3
X_4034_ _7150_/Q _4434_/B1 _4032_/X _4033_/X VGND VGND VPWR VPWR _4034_/X sky130_fd_sc_hd__a211o_2
XFILLER_25_604 VGND VGND VPWR VPWR sky130_fd_sc_hd__decap_3
XFILLER_80_710 VGND VGND VPWR VPWR sky130_fd_sc_hd__decap_3
XFILLER_25_626 VGND VGND VPWR VPWR sky130_fd_sc_hd__decap_3
XFILLER_25_659 VGND VGND VPWR VPWR sky130_fd_sc_hd__decap_3
XFILLER_37_497 VGND VGND VPWR VPWR sky130_fd_sc_hd__decap_3
XFILLER_64_283 VGND VGND VPWR VPWR sky130_fd_sc_hd__decap_3
XFILLER_92_581 VGND VGND VPWR VPWR sky130_fd_sc_hd__fill_1
XFILLER_24_147 VGND VGND VPWR VPWR sky130_fd_sc_hd__decap_3
XFILLER_40_607 VGND VGND VPWR VPWR sky130_fd_sc_hd__decap_3
XFILLER_52_489 VGND VGND VPWR VPWR sky130_fd_sc_hd__decap_3
X_4936_ _4936_/A _4936_/B VGND VGND VPWR VPWR _4936_/Y sky130_fd_sc_hd__xnor2_2
XTAP_TAPCELL_ROW_35_698 VGND VPWR sky130_fd_sc_hd__tapvpwrvgnd_1
X_4867_ _6998_/Q _4912_/A VGND VGND VPWR VPWR _4882_/A sky130_fd_sc_hd__nand2_2
XTAP_TAPCELL_ROW_82_1284 VGND VPWR sky130_fd_sc_hd__tapvpwrvgnd_1
X_6606_ _6608_/A VGND VGND VPWR VPWR _6606_/Y sky130_fd_sc_hd__inv_2
X_3818_ _3818_/A1 _3864_/S _3817_/X VGND VGND VPWR VPWR _7390_/D sky130_fd_sc_hd__o21a_2
X_6537_ _6638_/A VGND VGND VPWR VPWR _6537_/Y sky130_fd_sc_hd__inv_2
X_4798_ _4811_/C _4795_/X _4796_/Y _4797_/X VGND VGND VPWR VPWR _5656_/A sky130_fd_sc_hd__a211o_2
XFILLER_21_69 VGND VGND VPWR VPWR sky130_fd_sc_hd__decap_3
X_3749_ _3726_/X _3734_/X _3748_/X _3991_/A VGND VGND VPWR VPWR _3749_/Y sky130_fd_sc_hd__o31ai_2
XFILLER_106_436 VGND VGND VPWR VPWR sky130_fd_sc_hd__decap_3
X_6468_ _6662_/A VGND VGND VPWR VPWR _6468_/Y sky130_fd_sc_hd__inv_2
X_6399_ _6627_/A VGND VGND VPWR VPWR _6399_/Y sky130_fd_sc_hd__inv_2
X_5419_ _5419_/A0 _5131_/X _5429_/S VGND VGND VPWR VPWR _7124_/D sky130_fd_sc_hd__mux2_2
XFILLER_102_631 VGND VGND VPWR VPWR sky130_fd_sc_hd__decap_3
XTAP_TAPCELL_ROW_7_346 VGND VPWR sky130_fd_sc_hd__tapvpwrvgnd_1
XFILLER_48_707 VGND VGND VPWR VPWR sky130_fd_sc_hd__decap_3
XFILLER_87_364 VGND VGND VPWR VPWR sky130_fd_sc_hd__decap_3
XFILLER_99_191 VGND VGND VPWR VPWR sky130_fd_sc_hd__decap_3
XFILLER_101_152 VGND VGND VPWR VPWR sky130_fd_sc_hd__fill_2
XFILLER_102_675 VGND VGND VPWR VPWR sky130_fd_sc_hd__decap_3
XFILLER_47_217 VGND VGND VPWR VPWR sky130_fd_sc_hd__decap_3
XFILLER_47_228 VGND VGND VPWR VPWR sky130_fd_sc_hd__decap_3
XFILLER_101_196 VGND VGND VPWR VPWR sky130_fd_sc_hd__fill_2
XFILLER_28_442 VGND VGND VPWR VPWR sky130_fd_sc_hd__fill_2
XFILLER_16_604 VGND VGND VPWR VPWR sky130_fd_sc_hd__decap_3
XFILLER_28_475 VGND VGND VPWR VPWR sky130_fd_sc_hd__fill_1
XFILLER_55_261 VGND VGND VPWR VPWR sky130_fd_sc_hd__decap_3
XFILLER_90_507 VGND VGND VPWR VPWR sky130_fd_sc_hd__decap_3
XFILLER_16_637 VGND VGND VPWR VPWR sky130_fd_sc_hd__decap_3
XFILLER_16_648 VGND VGND VPWR VPWR sky130_fd_sc_hd__decap_3
XFILLER_28_486 VGND VGND VPWR VPWR sky130_fd_sc_hd__decap_3
XFILLER_43_434 VGND VGND VPWR VPWR sky130_fd_sc_hd__decap_3
XFILLER_46_88 VGND VGND VPWR VPWR sky130_fd_sc_hd__fill_2
XTAP_TAPCELL_ROW_54_930 VGND VPWR sky130_fd_sc_hd__tapvpwrvgnd_1
XFILLER_102_61 VGND VGND VPWR VPWR sky130_fd_sc_hd__decap_3
XFILLER_31_607 VGND VGND VPWR VPWR sky130_fd_sc_hd__decap_3
XFILLER_43_467 VGND VGND VPWR VPWR sky130_fd_sc_hd__decap_3
XFILLER_70_242 VGND VGND VPWR VPWR sky130_fd_sc_hd__decap_3
XFILLER_70_253 VGND VGND VPWR VPWR sky130_fd_sc_hd__decap_3
XFILLER_102_83 VGND VGND VPWR VPWR sky130_fd_sc_hd__fill_1
XFILLER_102_94 VGND VGND VPWR VPWR sky130_fd_sc_hd__decap_3
XFILLER_24_681 VGND VGND VPWR VPWR sky130_fd_sc_hd__decap_3
XFILLER_31_629 VGND VGND VPWR VPWR sky130_fd_sc_hd__decap_3
XFILLER_70_264 VGND VGND VPWR VPWR sky130_fd_sc_hd__decap_3
XFILLER_70_286 VGND VGND VPWR VPWR sky130_fd_sc_hd__fill_1
XFILLER_30_139 VGND VGND VPWR VPWR sky130_fd_sc_hd__fill_1
XFILLER_7_302 VGND VGND VPWR VPWR sky130_fd_sc_hd__decap_3
XFILLER_7_346 VGND VGND VPWR VPWR sky130_fd_sc_hd__decap_3
XFILLER_109_252 VGND VGND VPWR VPWR sky130_fd_sc_hd__decap_3
XFILLER_7_379 VGND VGND VPWR VPWR sky130_fd_sc_hd__fill_2
XFILLER_109_296 VGND VGND VPWR VPWR sky130_fd_sc_hd__decap_3
XFILLER_3_541 VGND VGND VPWR VPWR sky130_fd_sc_hd__decap_3
XFILLER_98_618 VGND VGND VPWR VPWR sky130_fd_sc_hd__decap_3
XFILLER_3_585 VGND VGND VPWR VPWR sky130_fd_sc_hd__decap_3
XFILLER_87_84 VGND VGND VPWR VPWR sky130_fd_sc_hd__fill_2
XFILLER_78_375 VGND VGND VPWR VPWR sky130_fd_sc_hd__decap_3
XFILLER_19_464 VGND VGND VPWR VPWR sky130_fd_sc_hd__decap_3
XFILLER_53_209 VGND VGND VPWR VPWR sky130_fd_sc_hd__decap_3
XFILLER_62_710 VGND VGND VPWR VPWR sky130_fd_sc_hd__decap_3
XFILLER_46_283 VGND VGND VPWR VPWR sky130_fd_sc_hd__decap_3
XFILLER_74_570 VGND VGND VPWR VPWR sky130_fd_sc_hd__fill_1
XFILLER_22_607 VGND VGND VPWR VPWR sky130_fd_sc_hd__decap_3
XFILLER_61_242 VGND VGND VPWR VPWR sky130_fd_sc_hd__decap_3
XFILLER_21_106 VGND VGND VPWR VPWR sky130_fd_sc_hd__decap_3
XFILLER_34_489 VGND VGND VPWR VPWR sky130_fd_sc_hd__decap_3
XFILLER_99_3 VGND VGND VPWR VPWR sky130_fd_sc_hd__decap_3
XFILLER_21_128 VGND VGND VPWR VPWR sky130_fd_sc_hd__fill_1
XFILLER_30_640 VGND VGND VPWR VPWR sky130_fd_sc_hd__decap_3
X_4721_ _5071_/A _4658_/A _4055_/A VGND VGND VPWR VPWR _4721_/Y sky130_fd_sc_hd__a21oi_2
XTAP_TAPCELL_ROW_32_657 VGND VPWR sky130_fd_sc_hd__tapvpwrvgnd_1
XFILLER_30_651 VGND VGND VPWR VPWR sky130_fd_sc_hd__decap_3
X_4652_ _4652_/A _4652_/B VGND VGND VPWR VPWR _4785_/A sky130_fd_sc_hd__nor2_2
XFILLER_30_684 VGND VGND VPWR VPWR sky130_fd_sc_hd__decap_3
X_3603_ _4614_/B _3603_/B VGND VGND VPWR VPWR _3603_/Y sky130_fd_sc_hd__nand2_2
XFILLER_116_701 VGND VGND VPWR VPWR sky130_fd_sc_hd__decap_3
X_7371_ _7371_/CLK _7371_/D _6651_/Y VGND VGND VPWR VPWR _7371_/Q sky130_fd_sc_hd__dfrtp_2
Xhold803 _6818_/Q VGND VGND VPWR VPWR _6818_/D sky130_fd_sc_hd__dlygate4sd3_1
X_4583_ _4583_/A _4593_/B VGND VGND VPWR VPWR _7289_/D sky130_fd_sc_hd__and2_2
XFILLER_115_211 VGND VGND VPWR VPWR sky130_fd_sc_hd__decap_3
Xhold814 _6820_/Q VGND VGND VPWR VPWR _6820_/D sky130_fd_sc_hd__dlygate4sd3_1
Xhold825 _6957_/Q VGND VGND VPWR VPWR _6957_/D sky130_fd_sc_hd__dlygate4sd3_1
Xhold836 _6921_/Q VGND VGND VPWR VPWR _6921_/D sky130_fd_sc_hd__dlygate4sd3_1
X_6322_ _6544_/A VGND VGND VPWR VPWR _6322_/Y sky130_fd_sc_hd__inv_2
X_3534_ _3509_/Y _3510_/X _3380_/Y VGND VGND VPWR VPWR _3534_/Y sky130_fd_sc_hd__a21oi_2
XFILLER_115_244 VGND VGND VPWR VPWR sky130_fd_sc_hd__fill_2
XFILLER_115_255 VGND VGND VPWR VPWR sky130_fd_sc_hd__fill_1
XFILLER_89_629 VGND VGND VPWR VPWR sky130_fd_sc_hd__decap_3
Xhold847 _6860_/Q VGND VGND VPWR VPWR _6860_/D sky130_fd_sc_hd__dlygate4sd3_1
Xhold858 _6849_/Q VGND VGND VPWR VPWR _6849_/D sky130_fd_sc_hd__dlygate4sd3_1
Xhold869 _6954_/Q VGND VGND VPWR VPWR _6954_/D sky130_fd_sc_hd__dlygate4sd3_1
X_3465_ _7185_/Q _4471_/S _4346_/B1 _7377_/Q VGND VGND VPWR VPWR _3465_/X sky130_fd_sc_hd__a22o_2
XFILLER_103_417 VGND VGND VPWR VPWR sky130_fd_sc_hd__decap_3
XFILLER_115_277 VGND VGND VPWR VPWR sky130_fd_sc_hd__decap_3
XFILLER_69_320 VGND VGND VPWR VPWR sky130_fd_sc_hd__fill_2
XFILLER_88_117 VGND VGND VPWR VPWR sky130_fd_sc_hd__decap_3
XFILLER_97_662 VGND VGND VPWR VPWR sky130_fd_sc_hd__decap_3
XTAP_TAPCELL_ROW_4_305 VGND VPWR sky130_fd_sc_hd__tapvpwrvgnd_1
XFILLER_111_472 VGND VGND VPWR VPWR sky130_fd_sc_hd__decap_3
XFILLER_29_217 VGND VGND VPWR VPWR sky130_fd_sc_hd__decap_3
XFILLER_69_364 VGND VGND VPWR VPWR sky130_fd_sc_hd__decap_3
XFILLER_96_150 VGND VGND VPWR VPWR sky130_fd_sc_hd__decap_3
XFILLER_97_673 VGND VGND VPWR VPWR sky130_fd_sc_hd__decap_3
X_5135_ _3324_/A _5642_/A _5595_/B _5134_/X VGND VGND VPWR VPWR _5135_/X sky130_fd_sc_hd__a211o_2
XFILLER_111_483 VGND VGND VPWR VPWR sky130_fd_sc_hd__decap_3
XFILLER_29_228 VGND VGND VPWR VPWR sky130_fd_sc_hd__fill_2
XFILLER_57_548 VGND VGND VPWR VPWR sky130_fd_sc_hd__decap_3
XFILLER_96_183 VGND VGND VPWR VPWR sky130_fd_sc_hd__decap_3
X_5066_ _5066_/A _5066_/B VGND VGND VPWR VPWR _6987_/D sky130_fd_sc_hd__nor2_2
XFILLER_72_507 VGND VGND VPWR VPWR sky130_fd_sc_hd__decap_3
XFILLER_84_356 VGND VGND VPWR VPWR sky130_fd_sc_hd__decap_3
X_4017_ _7310_/Q _4419_/A2 _4421_/B1 _7182_/Q VGND VGND VPWR VPWR _4017_/X sky130_fd_sc_hd__a22o_2
XFILLER_25_401 VGND VGND VPWR VPWR sky130_fd_sc_hd__decap_3
XTAP_TAPCELL_ROW_84_1313 VGND VPWR sky130_fd_sc_hd__tapvpwrvgnd_1
XTAP_TAPCELL_ROW_84_1302 VGND VPWR sky130_fd_sc_hd__tapvpwrvgnd_1
XFILLER_52_242 VGND VGND VPWR VPWR sky130_fd_sc_hd__decap_3
XFILLER_12_117 VGND VGND VPWR VPWR sky130_fd_sc_hd__decap_3
XFILLER_13_629 VGND VGND VPWR VPWR sky130_fd_sc_hd__decap_3
XFILLER_40_415 VGND VGND VPWR VPWR sky130_fd_sc_hd__decap_3
XFILLER_52_264 VGND VGND VPWR VPWR sky130_fd_sc_hd__decap_3
XTAP_TAPCELL_ROW_51_900 VGND VPWR sky130_fd_sc_hd__tapvpwrvgnd_1
XFILLER_52_297 VGND VGND VPWR VPWR sky130_fd_sc_hd__decap_3
X_4919_ _4937_/A _4936_/B _4938_/B VGND VGND VPWR VPWR _4920_/B sky130_fd_sc_hd__o21ba_2
XFILLER_21_662 VGND VGND VPWR VPWR sky130_fd_sc_hd__decap_3
XFILLER_21_673 VGND VGND VPWR VPWR sky130_fd_sc_hd__decap_3
XFILLER_107_712 VGND VGND VPWR VPWR sky130_fd_sc_hd__fill_2
XFILLER_119_561 VGND VGND VPWR VPWR sky130_fd_sc_hd__fill_1
XTAP_TAPCELL_ROW_95_1442 VGND VPWR sky130_fd_sc_hd__tapvpwrvgnd_1
XFILLER_106_244 VGND VGND VPWR VPWR sky130_fd_sc_hd__decap_3
XFILLER_0_511 VGND VGND VPWR VPWR sky130_fd_sc_hd__decap_3
XFILLER_0_522 VGND VGND VPWR VPWR sky130_fd_sc_hd__decap_3
XFILLER_106_277 VGND VGND VPWR VPWR sky130_fd_sc_hd__fill_1
XFILLER_79_128 VGND VGND VPWR VPWR sky130_fd_sc_hd__fill_1
XFILLER_0_533 VGND VGND VPWR VPWR sky130_fd_sc_hd__decap_3
XFILLER_0_555 VGND VGND VPWR VPWR sky130_fd_sc_hd__decap_3
XFILLER_88_651 VGND VGND VPWR VPWR sky130_fd_sc_hd__decap_3
XFILLER_102_461 VGND VGND VPWR VPWR sky130_fd_sc_hd__decap_3
XFILLER_48_504 VGND VGND VPWR VPWR sky130_fd_sc_hd__fill_1
XFILLER_48_526 VGND VGND VPWR VPWR sky130_fd_sc_hd__decap_3
XFILLER_87_172 VGND VGND VPWR VPWR sky130_fd_sc_hd__decap_3
XFILLER_88_684 VGND VGND VPWR VPWR sky130_fd_sc_hd__decap_3
XFILLER_94_109 VGND VGND VPWR VPWR sky130_fd_sc_hd__decap_3
XFILLER_57_54 VGND VGND VPWR VPWR sky130_fd_sc_hd__fill_2
XFILLER_63_529 VGND VGND VPWR VPWR sky130_fd_sc_hd__decap_3
XFILLER_75_356 VGND VGND VPWR VPWR sky130_fd_sc_hd__fill_1
XFILLER_75_378 VGND VGND VPWR VPWR sky130_fd_sc_hd__decap_3
XFILLER_113_60 VGND VGND VPWR VPWR sky130_fd_sc_hd__decap_3
XFILLER_44_710 VGND VGND VPWR VPWR sky130_fd_sc_hd__decap_3
XFILLER_73_20 VGND VGND VPWR VPWR sky130_fd_sc_hd__fill_2
XFILLER_90_315 VGND VGND VPWR VPWR sky130_fd_sc_hd__decap_3
XFILLER_90_348 VGND VGND VPWR VPWR sky130_fd_sc_hd__decap_3
Xplace507 _6982_/Q VGND VGND VPWR VPWR _5129_/A sky130_fd_sc_hd__buf_2
Xplace518 _6653_/A VGND VGND VPWR VPWR _6621_/A sky130_fd_sc_hd__buf_2
Xplace529 _6686_/A VGND VGND VPWR VPWR _6617_/A sky130_fd_sc_hd__buf_2
XFILLER_113_93 VGND VGND VPWR VPWR sky130_fd_sc_hd__decap_3
XFILLER_16_445 VGND VGND VPWR VPWR sky130_fd_sc_hd__decap_3
XFILLER_28_294 VGND VGND VPWR VPWR sky130_fd_sc_hd__fill_1
XFILLER_43_220 VGND VGND VPWR VPWR sky130_fd_sc_hd__decap_3
XFILLER_43_231 VGND VGND VPWR VPWR sky130_fd_sc_hd__decap_3
XFILLER_16_489 VGND VGND VPWR VPWR sky130_fd_sc_hd__decap_3
XFILLER_43_253 VGND VGND VPWR VPWR sky130_fd_sc_hd__decap_3
XFILLER_43_275 VGND VGND VPWR VPWR sky130_fd_sc_hd__decap_3
XFILLER_73_86 VGND VGND VPWR VPWR sky130_fd_sc_hd__decap_3
XTAP_TAPCELL_ROW_104_1560 VGND VPWR sky130_fd_sc_hd__tapvpwrvgnd_1
XFILLER_12_640 VGND VGND VPWR VPWR sky130_fd_sc_hd__decap_3
XFILLER_12_651 VGND VGND VPWR VPWR sky130_fd_sc_hd__decap_3
XFILLER_8_622 VGND VGND VPWR VPWR sky130_fd_sc_hd__decap_3
XFILLER_11_161 VGND VGND VPWR VPWR sky130_fd_sc_hd__decap_3
XFILLER_12_684 VGND VGND VPWR VPWR sky130_fd_sc_hd__decap_3
XFILLER_7_132 VGND VGND VPWR VPWR sky130_fd_sc_hd__decap_3
XFILLER_7_165 VGND VGND VPWR VPWR sky130_fd_sc_hd__decap_3
XFILLER_8_666 VGND VGND VPWR VPWR sky130_fd_sc_hd__decap_3
XFILLER_8_699 VGND VGND VPWR VPWR sky130_fd_sc_hd__fill_1
XFILLER_3_371 VGND VGND VPWR VPWR sky130_fd_sc_hd__fill_1
XFILLER_98_83 VGND VGND VPWR VPWR sky130_fd_sc_hd__fill_1
XFILLER_3_382 VGND VGND VPWR VPWR sky130_fd_sc_hd__decap_3
XFILLER_3_393 VGND VGND VPWR VPWR sky130_fd_sc_hd__decap_3
XFILLER_39_526 VGND VGND VPWR VPWR sky130_fd_sc_hd__decap_3
XFILLER_66_312 VGND VGND VPWR VPWR sky130_fd_sc_hd__decap_3
XFILLER_79_662 VGND VGND VPWR VPWR sky130_fd_sc_hd__decap_3
XFILLER_79_673 VGND VGND VPWR VPWR sky130_fd_sc_hd__decap_3
XFILLER_94_610 VGND VGND VPWR VPWR sky130_fd_sc_hd__decap_3
XFILLER_66_334 VGND VGND VPWR VPWR sky130_fd_sc_hd__decap_3
XFILLER_78_172 VGND VGND VPWR VPWR sky130_fd_sc_hd__decap_3
XFILLER_93_131 VGND VGND VPWR VPWR sky130_fd_sc_hd__decap_3
XFILLER_94_643 VGND VGND VPWR VPWR sky130_fd_sc_hd__fill_1
XFILLER_94_654 VGND VGND VPWR VPWR sky130_fd_sc_hd__decap_3
XFILLER_26_209 VGND VGND VPWR VPWR sky130_fd_sc_hd__decap_3
XFILLER_94_687 VGND VGND VPWR VPWR sky130_fd_sc_hd__decap_3
X_6940_ _6941_/CLK _6940_/D VGND VGND VPWR VPWR _6940_/Q sky130_fd_sc_hd__dfxtp_2
XTAP_TAPCELL_ROW_37_716 VGND VPWR sky130_fd_sc_hd__tapvpwrvgnd_1
XFILLER_47_592 VGND VGND VPWR VPWR sky130_fd_sc_hd__decap_3
XFILLER_81_337 VGND VGND VPWR VPWR sky130_fd_sc_hd__decap_3
XFILLER_34_220 VGND VGND VPWR VPWR sky130_fd_sc_hd__decap_3
X_6871_ _6922_/CLK _6871_/D VGND VGND VPWR VPWR _6871_/Q sky130_fd_sc_hd__dfxtp_2
XFILLER_34_253 VGND VGND VPWR VPWR sky130_fd_sc_hd__decap_3
XFILLER_50_713 VGND VGND VPWR VPWR sky130_fd_sc_hd__fill_1
XTAP_TAPCELL_ROW_66_1087 VGND VPWR sky130_fd_sc_hd__tapvpwrvgnd_1
XTAP_TAPCELL_ROW_17_473 VGND VPWR sky130_fd_sc_hd__tapvpwrvgnd_1
XFILLER_34_286 VGND VGND VPWR VPWR sky130_fd_sc_hd__decap_3
X_4704_ _6994_/Q _4977_/A VGND VGND VPWR VPWR _4963_/A sky130_fd_sc_hd__and2_2
XFILLER_30_492 VGND VGND VPWR VPWR sky130_fd_sc_hd__decap_3
X_5684_ _7348_/Q _5684_/A1 _5708_/S VGND VGND VPWR VPWR _6692_/D sky130_fd_sc_hd__mux2_2
X_4635_ _4916_/A _4916_/B _4633_/X _4634_/Y VGND VGND VPWR VPWR _4646_/A sky130_fd_sc_hd__a211o_2
XTAP_TAPCELL_ROW_118_1729 VGND VPWR sky130_fd_sc_hd__tapvpwrvgnd_1
XFILLER_116_531 VGND VGND VPWR VPWR sky130_fd_sc_hd__fill_1
XFILLER_118_38 VGND VGND VPWR VPWR sky130_fd_sc_hd__decap_3
X_7354_ _7354_/CLK _7354_/D _6634_/Y VGND VGND VPWR VPWR _7354_/Q sky130_fd_sc_hd__dfrtp_2
XFILLER_104_704 VGND VGND VPWR VPWR sky130_fd_sc_hd__decap_3
XFILLER_116_553 VGND VGND VPWR VPWR sky130_fd_sc_hd__decap_3
X_6305_ _6622_/A VGND VGND VPWR VPWR _6305_/Y sky130_fd_sc_hd__inv_2
X_3517_ _3386_/B _3370_/Y _3516_/X VGND VGND VPWR VPWR _3525_/A sky130_fd_sc_hd__a21bo_2
XFILLER_103_214 VGND VGND VPWR VPWR sky130_fd_sc_hd__decap_3
XFILLER_89_415 VGND VGND VPWR VPWR sky130_fd_sc_hd__decap_3
X_7285_ _7350_/CLK _7285_/D _6565_/Y VGND VGND VPWR VPWR _7285_/Q sky130_fd_sc_hd__dfrtp_2
Xhold688 _6856_/Q VGND VGND VPWR VPWR _6856_/D sky130_fd_sc_hd__dlygate4sd3_1
X_4497_ _4497_/A0 _7299_/Q _4497_/S VGND VGND VPWR VPWR _7331_/D sky130_fd_sc_hd__mux2_2
XFILLER_103_258 VGND VGND VPWR VPWR sky130_fd_sc_hd__decap_3
Xhold699 _6922_/Q VGND VGND VPWR VPWR _6922_/D sky130_fd_sc_hd__dlygate4sd3_1
X_3448_ _7282_/Q _4335_/A2 _4352_/B1 _7154_/Q _3447_/X VGND VGND VPWR VPWR _3448_/X
+ sky130_fd_sc_hd__a221o_2
Xhold1300 _6699_/Q VGND VGND VPWR VPWR _5699_/A1 sky130_fd_sc_hd__dlygate4sd3_1
X_3379_ _7219_/Q _3377_/X _5229_/C _7123_/Q VGND VGND VPWR VPWR _3379_/X sky130_fd_sc_hd__a22o_2
XTAP_TAPCELL_ROW_90_1383 VGND VPWR sky130_fd_sc_hd__tapvpwrvgnd_1
XFILLER_57_334 VGND VGND VPWR VPWR sky130_fd_sc_hd__fill_2
XFILLER_69_172 VGND VGND VPWR VPWR sky130_fd_sc_hd__decap_3
XFILLER_85_632 VGND VGND VPWR VPWR sky130_fd_sc_hd__decap_3
Xhold1311 _7228_/Q VGND VGND VPWR VPWR _5200_/A sky130_fd_sc_hd__dlygate4sd3_1
Xhold1322 _7151_/Q VGND VGND VPWR VPWR _5360_/A0 sky130_fd_sc_hd__dlygate4sd3_1
X_5118_ _5118_/A _6984_/Q _5118_/C _5118_/D VGND VGND VPWR VPWR _5118_/X sky130_fd_sc_hd__or4_2
XFILLER_84_164 VGND VGND VPWR VPWR sky130_fd_sc_hd__decap_3
XFILLER_85_665 VGND VGND VPWR VPWR sky130_fd_sc_hd__decap_3
XFILLER_85_676 VGND VGND VPWR VPWR sky130_fd_sc_hd__decap_3
XFILLER_26_710 VGND VGND VPWR VPWR sky130_fd_sc_hd__decap_3
XFILLER_38_592 VGND VGND VPWR VPWR sky130_fd_sc_hd__decap_3
XFILLER_84_197 VGND VGND VPWR VPWR sky130_fd_sc_hd__decap_3
X_5049_ _5072_/B _5073_/B _5071_/B VGND VGND VPWR VPWR _5049_/X sky130_fd_sc_hd__a21bo_2
XFILLER_27_79 VGND VGND VPWR VPWR sky130_fd_sc_hd__fill_1
XFILLER_13_415 VGND VGND VPWR VPWR sky130_fd_sc_hd__fill_2
XFILLER_53_573 VGND VGND VPWR VPWR sky130_fd_sc_hd__fill_2
XFILLER_40_212 VGND VGND VPWR VPWR sky130_fd_sc_hd__decap_3
XFILLER_40_256 VGND VGND VPWR VPWR sky130_fd_sc_hd__fill_1
XFILLER_40_289 VGND VGND VPWR VPWR sky130_fd_sc_hd__decap_3
XFILLER_5_603 VGND VGND VPWR VPWR sky130_fd_sc_hd__decap_3
XFILLER_5_647 VGND VGND VPWR VPWR sky130_fd_sc_hd__decap_3
XFILLER_107_542 VGND VGND VPWR VPWR sky130_fd_sc_hd__decap_3
XFILLER_107_564 VGND VGND VPWR VPWR sky130_fd_sc_hd__fill_2
XFILLER_107_575 VGND VGND VPWR VPWR sky130_fd_sc_hd__decap_3
XFILLER_107_586 VGND VGND VPWR VPWR sky130_fd_sc_hd__decap_3
XFILLER_108_71 VGND VGND VPWR VPWR sky130_fd_sc_hd__decap_3
XFILLER_0_330 VGND VGND VPWR VPWR sky130_fd_sc_hd__decap_3
XFILLER_108_93 VGND VGND VPWR VPWR sky130_fd_sc_hd__decap_3
XFILLER_110_707 VGND VGND VPWR VPWR sky130_fd_sc_hd__decap_3
XFILLER_0_363 VGND VGND VPWR VPWR sky130_fd_sc_hd__fill_1
XFILLER_67_109 VGND VGND VPWR VPWR sky130_fd_sc_hd__decap_3
XFILLER_102_280 VGND VGND VPWR VPWR sky130_fd_sc_hd__decap_3
XFILLER_48_312 VGND VGND VPWR VPWR sky130_fd_sc_hd__decap_3
XFILLER_75_120 VGND VGND VPWR VPWR sky130_fd_sc_hd__decap_3
XFILLER_76_621 VGND VGND VPWR VPWR sky130_fd_sc_hd__decap_3
XFILLER_88_492 VGND VGND VPWR VPWR sky130_fd_sc_hd__decap_3
XFILLER_48_378 VGND VGND VPWR VPWR sky130_fd_sc_hd__decap_3
XFILLER_63_304 VGND VGND VPWR VPWR sky130_fd_sc_hd__decap_3
XFILLER_75_153 VGND VGND VPWR VPWR sky130_fd_sc_hd__decap_3
XFILLER_76_654 VGND VGND VPWR VPWR sky130_fd_sc_hd__decap_3
XFILLER_76_687 VGND VGND VPWR VPWR sky130_fd_sc_hd__decap_3
XFILLER_91_613 VGND VGND VPWR VPWR sky130_fd_sc_hd__decap_3
XFILLER_29_570 VGND VGND VPWR VPWR sky130_fd_sc_hd__decap_3
XFILLER_36_529 VGND VGND VPWR VPWR sky130_fd_sc_hd__decap_3
XFILLER_75_175 VGND VGND VPWR VPWR sky130_fd_sc_hd__decap_3
XFILLER_84_63 VGND VGND VPWR VPWR sky130_fd_sc_hd__fill_2
XFILLER_90_112 VGND VGND VPWR VPWR sky130_fd_sc_hd__decap_3
XFILLER_91_635 VGND VGND VPWR VPWR sky130_fd_sc_hd__decap_3
XFILLER_84_85 VGND VGND VPWR VPWR sky130_fd_sc_hd__decap_3
XFILLER_91_668 VGND VGND VPWR VPWR sky130_fd_sc_hd__decap_3
XFILLER_91_679 VGND VGND VPWR VPWR sky130_fd_sc_hd__decap_3
Xplace337 _3661_/X VGND VGND VPWR VPWR _3851_/A2 sky130_fd_sc_hd__buf_2
Xplace326 _3911_/B1 VGND VGND VPWR VPWR _3887_/B1 sky130_fd_sc_hd__buf_2
XFILLER_16_253 VGND VGND VPWR VPWR sky130_fd_sc_hd__decap_3
XFILLER_17_90 VGND VGND VPWR VPWR sky130_fd_sc_hd__decap_3
XFILLER_32_713 VGND VGND VPWR VPWR sky130_fd_sc_hd__fill_1
XFILLER_44_562 VGND VGND VPWR VPWR sky130_fd_sc_hd__fill_1
XFILLER_44_573 VGND VGND VPWR VPWR sky130_fd_sc_hd__fill_2
Xplace359 _5103_/A1 VGND VGND VPWR VPWR _4811_/C sky130_fd_sc_hd__buf_2
Xplace348 _3879_/B1 VGND VGND VPWR VPWR _3840_/A2 sky130_fd_sc_hd__buf_2
XFILLER_16_286 VGND VGND VPWR VPWR sky130_fd_sc_hd__decap_3
XFILLER_31_223 VGND VGND VPWR VPWR sky130_fd_sc_hd__fill_1
XFILLER_31_234 VGND VGND VPWR VPWR sky130_fd_sc_hd__decap_3
XFILLER_44_595 VGND VGND VPWR VPWR sky130_fd_sc_hd__decap_3
XTAP_TAPCELL_ROW_14_432 VGND VPWR sky130_fd_sc_hd__tapvpwrvgnd_1
XFILLER_12_470 VGND VGND VPWR VPWR sky130_fd_sc_hd__decap_3
XFILLER_8_430 VGND VGND VPWR VPWR sky130_fd_sc_hd__decap_3
XTAP_TAPCELL_ROW_42_785 VGND VPWR sky130_fd_sc_hd__tapvpwrvgnd_1
XFILLER_12_492 VGND VGND VPWR VPWR sky130_fd_sc_hd__decap_3
X_4420_ _7336_/Q _3952_/S _4428_/B1 _7144_/Q VGND VGND VPWR VPWR _4420_/X sky130_fd_sc_hd__a22o_2
X_4351_ _7097_/Q _4351_/A2 _4351_/B1 _7129_/Q VGND VGND VPWR VPWR _4351_/X sky130_fd_sc_hd__a22o_2
XFILLER_98_234 VGND VGND VPWR VPWR sky130_fd_sc_hd__fill_1
XFILLER_98_256 VGND VGND VPWR VPWR sky130_fd_sc_hd__decap_3
X_7070_ _7390_/CLK _7070_/D _6350_/Y VGND VGND VPWR VPWR _7070_/Q sky130_fd_sc_hd__dfrtp_2
X_4282_ _7062_/Q _3558_/B _3590_/A _4281_/X VGND VGND VPWR VPWR _4282_/Y sky130_fd_sc_hd__o211ai_2
X_3302_ _3327_/B _5129_/B _3324_/A VGND VGND VPWR VPWR _3302_/X sky130_fd_sc_hd__a21o_2
XFILLER_100_206 VGND VGND VPWR VPWR sky130_fd_sc_hd__decap_3
XFILLER_113_567 VGND VGND VPWR VPWR sky130_fd_sc_hd__decap_3
XFILLER_67_632 VGND VGND VPWR VPWR sky130_fd_sc_hd__decap_3
XFILLER_67_665 VGND VGND VPWR VPWR sky130_fd_sc_hd__decap_3
XFILLER_67_676 VGND VGND VPWR VPWR sky130_fd_sc_hd__decap_3
XTAP_TAPCELL_ROW_68_1105 VGND VPWR sky130_fd_sc_hd__tapvpwrvgnd_1
XFILLER_54_304 VGND VGND VPWR VPWR sky130_fd_sc_hd__decap_3
XFILLER_54_315 VGND VGND VPWR VPWR sky130_fd_sc_hd__decap_3
XFILLER_54_326 VGND VGND VPWR VPWR sky130_fd_sc_hd__fill_2
XFILLER_66_164 VGND VGND VPWR VPWR sky130_fd_sc_hd__decap_3
XFILLER_82_613 VGND VGND VPWR VPWR sky130_fd_sc_hd__decap_3
XFILLER_94_473 VGND VGND VPWR VPWR sky130_fd_sc_hd__decap_3
XFILLER_66_197 VGND VGND VPWR VPWR sky130_fd_sc_hd__decap_3
XFILLER_81_134 VGND VGND VPWR VPWR sky130_fd_sc_hd__decap_3
XFILLER_82_657 VGND VGND VPWR VPWR sky130_fd_sc_hd__decap_3
X_6923_ _6923_/CLK _6923_/D VGND VGND VPWR VPWR _6923_/Q sky130_fd_sc_hd__dfxtp_2
XFILLER_35_573 VGND VGND VPWR VPWR sky130_fd_sc_hd__decap_3
XFILLER_50_510 VGND VGND VPWR VPWR sky130_fd_sc_hd__decap_3
XFILLER_81_167 VGND VGND VPWR VPWR sky130_fd_sc_hd__fill_1
XFILLER_62_392 VGND VGND VPWR VPWR sky130_fd_sc_hd__fill_1
XFILLER_90_690 VGND VGND VPWR VPWR sky130_fd_sc_hd__decap_3
X_6854_ _6968_/CLK _6854_/D VGND VGND VPWR VPWR _6854_/Q sky130_fd_sc_hd__dfxtp_2
XFILLER_22_245 VGND VGND VPWR VPWR sky130_fd_sc_hd__decap_3
XFILLER_22_256 VGND VGND VPWR VPWR sky130_fd_sc_hd__decap_3
X_6785_ _6922_/CLK _6785_/D VGND VGND VPWR VPWR _6785_/Q sky130_fd_sc_hd__dfxtp_2
XFILLER_108_306 VGND VGND VPWR VPWR sky130_fd_sc_hd__fill_2
X_5667_ _5667_/A _5668_/B VGND VGND VPWR VPWR _6979_/D sky130_fd_sc_hd__nor2_2
X_7406_ _7406_/CLK _7406_/D _6686_/Y VGND VGND VPWR VPWR _7406_/Q sky130_fd_sc_hd__dfrtp_2
XTAP_TAPCELL_ROW_79_1245 VGND VPWR sky130_fd_sc_hd__tapvpwrvgnd_1
X_5598_ _5598_/A1 _5587_/B _4468_/X VGND VGND VPWR VPWR _7028_/D sky130_fd_sc_hd__a21o_2
XTAP_TAPCELL_ROW_92_1412 VGND VPWR sky130_fd_sc_hd__tapvpwrvgnd_1
XFILLER_104_501 VGND VGND VPWR VPWR sky130_fd_sc_hd__decap_3
XFILLER_116_361 VGND VGND VPWR VPWR sky130_fd_sc_hd__decap_3
XFILLER_2_628 VGND VGND VPWR VPWR sky130_fd_sc_hd__decap_3
X_7337_ _7402_/CLK _7337_/D _6617_/Y VGND VGND VPWR VPWR _7337_/Q sky130_fd_sc_hd__dfrtp_2
XFILLER_1_149 VGND VGND VPWR VPWR sky130_fd_sc_hd__fill_1
XFILLER_89_245 VGND VGND VPWR VPWR sky130_fd_sc_hd__decap_3
X_7268_ _7362_/CLK _7268_/D _6548_/Y VGND VGND VPWR VPWR _7268_/Q sky130_fd_sc_hd__dfrtp_2
XFILLER_104_589 VGND VGND VPWR VPWR sky130_fd_sc_hd__decap_3
XFILLER_58_610 VGND VGND VPWR VPWR sky130_fd_sc_hd__decap_3
XFILLER_77_429 VGND VGND VPWR VPWR sky130_fd_sc_hd__decap_3
XFILLER_58_643 VGND VGND VPWR VPWR sky130_fd_sc_hd__fill_1
X_7199_ _7358_/CLK _7199_/D _6479_/Y VGND VGND VPWR VPWR _7199_/Q sky130_fd_sc_hd__dfrtp_2
XFILLER_58_654 VGND VGND VPWR VPWR sky130_fd_sc_hd__decap_3
Xhold1130 _7260_/Q VGND VGND VPWR VPWR _5028_/A0 sky130_fd_sc_hd__dlygate4sd3_1
Xhold1141 _7208_/Q VGND VGND VPWR VPWR _5243_/A0 sky130_fd_sc_hd__dlygate4sd3_1
XFILLER_18_529 VGND VGND VPWR VPWR sky130_fd_sc_hd__decap_3
XFILLER_58_687 VGND VGND VPWR VPWR sky130_fd_sc_hd__decap_3
XFILLER_72_112 VGND VGND VPWR VPWR sky130_fd_sc_hd__decap_3
XFILLER_73_613 VGND VGND VPWR VPWR sky130_fd_sc_hd__decap_3
XFILLER_73_635 VGND VGND VPWR VPWR sky130_fd_sc_hd__decap_3
Xhold1152 _7283_/Q VGND VGND VPWR VPWR _4595_/A sky130_fd_sc_hd__dlygate4sd3_1
Xhold1163 _7224_/Q VGND VGND VPWR VPWR _5209_/A sky130_fd_sc_hd__dlygate4sd3_1
Xhold1174 _7336_/Q VGND VGND VPWR VPWR _4486_/A0 sky130_fd_sc_hd__dlygate4sd3_1
Xhold1185 _7341_/Q VGND VGND VPWR VPWR _4476_/A0 sky130_fd_sc_hd__dlygate4sd3_1
XFILLER_45_337 VGND VGND VPWR VPWR sky130_fd_sc_hd__decap_3
XFILLER_57_197 VGND VGND VPWR VPWR sky130_fd_sc_hd__decap_3
XFILLER_72_123 VGND VGND VPWR VPWR sky130_fd_sc_hd__decap_3
XFILLER_73_668 VGND VGND VPWR VPWR sky130_fd_sc_hd__decap_3
XFILLER_73_679 VGND VGND VPWR VPWR sky130_fd_sc_hd__decap_3
Xhold1196 _7289_/Q VGND VGND VPWR VPWR _4583_/A sky130_fd_sc_hd__dlygate4sd3_1
XFILLER_14_713 VGND VGND VPWR VPWR sky130_fd_sc_hd__fill_1
XFILLER_72_156 VGND VGND VPWR VPWR sky130_fd_sc_hd__decap_3
XFILLER_72_189 VGND VGND VPWR VPWR sky130_fd_sc_hd__decap_3
XFILLER_26_595 VGND VGND VPWR VPWR sky130_fd_sc_hd__decap_3
XFILLER_41_521 VGND VGND VPWR VPWR sky130_fd_sc_hd__fill_1
XFILLER_53_370 VGND VGND VPWR VPWR sky130_fd_sc_hd__fill_2
XFILLER_110_50 VGND VGND VPWR VPWR sky130_fd_sc_hd__decap_3
XFILLER_9_205 VGND VGND VPWR VPWR sky130_fd_sc_hd__decap_3
XFILLER_110_83 VGND VGND VPWR VPWR sky130_fd_sc_hd__fill_1
XFILLER_110_94 VGND VGND VPWR VPWR sky130_fd_sc_hd__decap_3
XFILLER_13_278 VGND VGND VPWR VPWR sky130_fd_sc_hd__fill_2
XFILLER_70_32 VGND VGND VPWR VPWR sky130_fd_sc_hd__fill_2
Xclkload19 _7354_/CLK VGND VGND VPWR VPWR clkload19/Y sky130_fd_sc_hd__clkinv_2
XFILLER_119_81 VGND VGND VPWR VPWR sky130_fd_sc_hd__decap_3
XFILLER_79_30 VGND VGND VPWR VPWR sky130_fd_sc_hd__fill_1
XFILLER_107_361 VGND VGND VPWR VPWR sky130_fd_sc_hd__decap_3
XFILLER_5_488 VGND VGND VPWR VPWR sky130_fd_sc_hd__decap_3
XFILLER_79_96 VGND VGND VPWR VPWR sky130_fd_sc_hd__decap_3
XFILLER_1_650 VGND VGND VPWR VPWR sky130_fd_sc_hd__decap_3
XFILLER_68_407 VGND VGND VPWR VPWR sky130_fd_sc_hd__decap_3
XFILLER_1_694 VGND VGND VPWR VPWR sky130_fd_sc_hd__fill_2
XFILLER_49_632 VGND VGND VPWR VPWR sky130_fd_sc_hd__decap_3
XFILLER_49_665 VGND VGND VPWR VPWR sky130_fd_sc_hd__decap_3
XFILLER_49_676 VGND VGND VPWR VPWR sky130_fd_sc_hd__decap_3
XFILLER_76_462 VGND VGND VPWR VPWR sky130_fd_sc_hd__decap_3
XFILLER_95_84 VGND VGND VPWR VPWR sky130_fd_sc_hd__fill_1
XFILLER_36_315 VGND VGND VPWR VPWR sky130_fd_sc_hd__decap_3
XFILLER_48_175 VGND VGND VPWR VPWR sky130_fd_sc_hd__decap_3
XFILLER_64_613 VGND VGND VPWR VPWR sky130_fd_sc_hd__decap_3
XFILLER_76_495 VGND VGND VPWR VPWR sky130_fd_sc_hd__decap_3
XFILLER_91_421 VGND VGND VPWR VPWR sky130_fd_sc_hd__decap_3
XFILLER_95_95 VGND VGND VPWR VPWR sky130_fd_sc_hd__decap_3
XFILLER_63_134 VGND VGND VPWR VPWR sky130_fd_sc_hd__decap_3
XFILLER_64_657 VGND VGND VPWR VPWR sky130_fd_sc_hd__decap_3
XTAP_TAPCELL_ROW_47_844 VGND VPWR sky130_fd_sc_hd__tapvpwrvgnd_1
XFILLER_51_307 VGND VGND VPWR VPWR sky130_fd_sc_hd__decap_3
X_3920_ _3920_/A1 _5151_/A _3919_/X VGND VGND VPWR VPWR _7377_/D sky130_fd_sc_hd__o21a_2
XFILLER_17_584 VGND VGND VPWR VPWR sky130_fd_sc_hd__decap_3
XFILLER_63_189 VGND VGND VPWR VPWR sky130_fd_sc_hd__decap_3
XFILLER_72_690 VGND VGND VPWR VPWR sky130_fd_sc_hd__decap_3
XFILLER_91_498 VGND VGND VPWR VPWR sky130_fd_sc_hd__decap_3
X_3851_ _6825_/Q _3851_/A2 _3853_/A2 _6815_/Q _3850_/X VGND VGND VPWR VPWR _3851_/X
+ sky130_fd_sc_hd__a221o_2
XTAP_TAPCELL_ROW_63_1046 VGND VPWR sky130_fd_sc_hd__tapvpwrvgnd_1
XTAP_TAPCELL_ROW_27_590 VGND VPWR sky130_fd_sc_hd__tapvpwrvgnd_1
XFILLER_32_598 VGND VGND VPWR VPWR sky130_fd_sc_hd__decap_3
X_6570_ _6570_/A VGND VGND VPWR VPWR _6570_/Y sky130_fd_sc_hd__inv_2
X_3782_ _6827_/Q _3661_/X _3840_/A2 _6817_/Q VGND VGND VPWR VPWR _3782_/X sky130_fd_sc_hd__a22o_2
XFILLER_118_604 VGND VGND VPWR VPWR sky130_fd_sc_hd__decap_3
XFILLER_118_637 VGND VGND VPWR VPWR sky130_fd_sc_hd__decap_3
XFILLER_118_648 VGND VGND VPWR VPWR sky130_fd_sc_hd__decap_3
XFILLER_117_158 VGND VGND VPWR VPWR sky130_fd_sc_hd__decap_3
XFILLER_8_293 VGND VGND VPWR VPWR sky130_fd_sc_hd__decap_3
XFILLER_117_169 VGND VGND VPWR VPWR sky130_fd_sc_hd__decap_3
X_5383_ _5383_/A0 _4878_/X _5390_/S VGND VGND VPWR VPWR _7141_/D sky130_fd_sc_hd__mux2_2
X_4403_ _4403_/A VGND VGND VPWR VPWR _4411_/A sky130_fd_sc_hd__inv_2
XFILLER_113_331 VGND VGND VPWR VPWR sky130_fd_sc_hd__decap_3
X_7122_ _7355_/CLK _7122_/D _6402_/Y VGND VGND VPWR VPWR _7122_/Q sky130_fd_sc_hd__dfrtp_2
X_4334_ _7351_/Q _4416_/A2 _4352_/B1 _7159_/Q VGND VGND VPWR VPWR _4336_/B sky130_fd_sc_hd__a22o_2
XFILLER_99_532 VGND VGND VPWR VPWR sky130_fd_sc_hd__decap_3
X_7053_ _7372_/CLK _7053_/D _6333_/Y VGND VGND VPWR VPWR _7053_/Q sky130_fd_sc_hd__dfrtp_2
Xoutput579 _4973_/B VGND VGND VPWR VPWR alu_result_out[16] sky130_fd_sc_hd__clkdlybuf4s25_1
XTAP_TAPCELL_ROW_74_1186 VGND VPWR sky130_fd_sc_hd__tapvpwrvgnd_1
XFILLER_115_39 VGND VGND VPWR VPWR sky130_fd_sc_hd__decap_3
XFILLER_86_215 VGND VGND VPWR VPWR sky130_fd_sc_hd__decap_3
X_4265_ _7070_/Q _4265_/B VGND VGND VPWR VPWR _4376_/C sky130_fd_sc_hd__nor2_2
XFILLER_86_259 VGND VGND VPWR VPWR sky130_fd_sc_hd__decap_3
X_4196_ _7391_/Q _4338_/B1 _4979_/S _7295_/Q _4195_/X VGND VGND VPWR VPWR _4196_/X
+ sky130_fd_sc_hd__a221o_2
XFILLER_27_315 VGND VGND VPWR VPWR sky130_fd_sc_hd__decap_3
XFILLER_39_153 VGND VGND VPWR VPWR sky130_fd_sc_hd__decap_3
XFILLER_39_175 VGND VGND VPWR VPWR sky130_fd_sc_hd__decap_3
XFILLER_55_635 VGND VGND VPWR VPWR sky130_fd_sc_hd__decap_3
XFILLER_54_123 VGND VGND VPWR VPWR sky130_fd_sc_hd__decap_3
XFILLER_55_668 VGND VGND VPWR VPWR sky130_fd_sc_hd__decap_3
XFILLER_94_281 VGND VGND VPWR VPWR sky130_fd_sc_hd__decap_3
XFILLER_42_318 VGND VGND VPWR VPWR sky130_fd_sc_hd__decap_3
XFILLER_54_156 VGND VGND VPWR VPWR sky130_fd_sc_hd__decap_3
XFILLER_55_679 VGND VGND VPWR VPWR sky130_fd_sc_hd__decap_3
XFILLER_70_616 VGND VGND VPWR VPWR sky130_fd_sc_hd__decap_3
XFILLER_35_381 VGND VGND VPWR VPWR sky130_fd_sc_hd__fill_2
XFILLER_54_189 VGND VGND VPWR VPWR sky130_fd_sc_hd__decap_3
XFILLER_82_498 VGND VGND VPWR VPWR sky130_fd_sc_hd__decap_3
X_6906_ _6906_/CLK _6906_/D VGND VGND VPWR VPWR _6906_/Q sky130_fd_sc_hd__dfxtp_2
XFILLER_24_25 VGND VGND VPWR VPWR sky130_fd_sc_hd__decap_3
X_6837_ clkload5/A _6837_/D VGND VGND VPWR VPWR _6837_/Q sky130_fd_sc_hd__dfxtp_2
XFILLER_50_362 VGND VGND VPWR VPWR sky130_fd_sc_hd__fill_2
XFILLER_10_248 VGND VGND VPWR VPWR sky130_fd_sc_hd__decap_3
XFILLER_7_709 VGND VGND VPWR VPWR sky130_fd_sc_hd__decap_3
X_6768_ _6906_/CLK _6768_/D VGND VGND VPWR VPWR _6768_/Q sky130_fd_sc_hd__dfxtp_2
XFILLER_108_125 VGND VGND VPWR VPWR sky130_fd_sc_hd__fill_1
XFILLER_109_626 VGND VGND VPWR VPWR sky130_fd_sc_hd__decap_3
X_6699_ _7350_/CLK _6699_/D VGND VGND VPWR VPWR _6699_/Q sky130_fd_sc_hd__dfxtp_2
X_5719_ _7365_/Q _5719_/A1 _5735_/S VGND VGND VPWR VPWR _6709_/D sky130_fd_sc_hd__mux2_2
XFILLER_108_136 VGND VGND VPWR VPWR sky130_fd_sc_hd__decap_3
XFILLER_109_659 VGND VGND VPWR VPWR sky130_fd_sc_hd__decap_3
XFILLER_116_180 VGND VGND VPWR VPWR sky130_fd_sc_hd__decap_3
XFILLER_49_11 VGND VGND VPWR VPWR sky130_fd_sc_hd__decap_3
XFILLER_104_342 VGND VGND VPWR VPWR sky130_fd_sc_hd__decap_3
XFILLER_49_55 VGND VGND VPWR VPWR sky130_fd_sc_hd__fill_1
XFILLER_104_386 VGND VGND VPWR VPWR sky130_fd_sc_hd__decap_3
XFILLER_100_570 VGND VGND VPWR VPWR sky130_fd_sc_hd__fill_1
XFILLER_105_83 VGND VGND VPWR VPWR sky130_fd_sc_hd__decap_3
XFILLER_18_315 VGND VGND VPWR VPWR sky130_fd_sc_hd__decap_3
XFILLER_46_613 VGND VGND VPWR VPWR sky130_fd_sc_hd__decap_3
XFILLER_92_229 VGND VGND VPWR VPWR sky130_fd_sc_hd__decap_3
XFILLER_18_348 VGND VGND VPWR VPWR sky130_fd_sc_hd__fill_2
XFILLER_46_657 VGND VGND VPWR VPWR sky130_fd_sc_hd__decap_3
XFILLER_65_54 VGND VGND VPWR VPWR sky130_fd_sc_hd__fill_2
XFILLER_73_432 VGND VGND VPWR VPWR sky130_fd_sc_hd__fill_1
XFILLER_85_281 VGND VGND VPWR VPWR sky130_fd_sc_hd__decap_3
XFILLER_45_156 VGND VGND VPWR VPWR sky130_fd_sc_hd__decap_3
XFILLER_61_605 VGND VGND VPWR VPWR sky130_fd_sc_hd__decap_3
XTAP_TAPCELL_ROW_44_814 VGND VPWR sky130_fd_sc_hd__tapvpwrvgnd_1
XTAP_TAPCELL_ROW_44_803 VGND VPWR sky130_fd_sc_hd__tapvpwrvgnd_1
XFILLER_14_521 VGND VGND VPWR VPWR sky130_fd_sc_hd__decap_3
XFILLER_33_329 VGND VGND VPWR VPWR sky130_fd_sc_hd__decap_3
XFILLER_45_189 VGND VGND VPWR VPWR sky130_fd_sc_hd__decap_3
XFILLER_54_690 VGND VGND VPWR VPWR sky130_fd_sc_hd__decap_3
XFILLER_61_638 VGND VGND VPWR VPWR sky130_fd_sc_hd__decap_3
XFILLER_41_340 VGND VGND VPWR VPWR sky130_fd_sc_hd__decap_3
XFILLER_14_576 VGND VGND VPWR VPWR sky130_fd_sc_hd__decap_3
XFILLER_14_598 VGND VGND VPWR VPWR sky130_fd_sc_hd__decap_3
XFILLER_81_75 VGND VGND VPWR VPWR sky130_fd_sc_hd__decap_3
XFILLER_81_86 VGND VGND VPWR VPWR sky130_fd_sc_hd__decap_3
XTAP_TAPCELL_ROW_24_560 VGND VPWR sky130_fd_sc_hd__tapvpwrvgnd_1
XFILLER_108_681 VGND VGND VPWR VPWR sky130_fd_sc_hd__decap_3
XFILLER_115_629 VGND VGND VPWR VPWR sky130_fd_sc_hd__decap_3
XFILLER_114_128 VGND VGND VPWR VPWR sky130_fd_sc_hd__fill_2
XFILLER_96_513 VGND VGND VPWR VPWR sky130_fd_sc_hd__decap_3
XTAP_TAPCELL_ROW_110_1629 VGND VPWR sky130_fd_sc_hd__tapvpwrvgnd_1
XFILLER_110_312 VGND VGND VPWR VPWR sky130_fd_sc_hd__decap_3
XFILLER_110_356 VGND VGND VPWR VPWR sky130_fd_sc_hd__decap_3
XFILLER_68_259 VGND VGND VPWR VPWR sky130_fd_sc_hd__decap_3
XFILLER_96_557 VGND VGND VPWR VPWR sky130_fd_sc_hd__fill_1
XFILLER_96_579 VGND VGND VPWR VPWR sky130_fd_sc_hd__decap_3
X_4050_ _7053_/Q _4488_/S _4181_/B1 _7405_/Q _4049_/X VGND VGND VPWR VPWR _4050_/X
+ sky130_fd_sc_hd__a221o_2
XFILLER_37_602 VGND VGND VPWR VPWR sky130_fd_sc_hd__decap_3
XFILLER_36_134 VGND VGND VPWR VPWR sky130_fd_sc_hd__decap_3
XFILLER_37_635 VGND VGND VPWR VPWR sky130_fd_sc_hd__decap_3
XFILLER_37_668 VGND VGND VPWR VPWR sky130_fd_sc_hd__decap_3
XFILLER_49_495 VGND VGND VPWR VPWR sky130_fd_sc_hd__decap_3
XFILLER_64_421 VGND VGND VPWR VPWR sky130_fd_sc_hd__decap_3
XFILLER_76_292 VGND VGND VPWR VPWR sky130_fd_sc_hd__decap_3
XFILLER_36_167 VGND VGND VPWR VPWR sky130_fd_sc_hd__decap_3
XFILLER_37_679 VGND VGND VPWR VPWR sky130_fd_sc_hd__decap_3
XFILLER_52_616 VGND VGND VPWR VPWR sky130_fd_sc_hd__decap_3
XFILLER_91_251 VGND VGND VPWR VPWR sky130_fd_sc_hd__decap_3
XFILLER_51_137 VGND VGND VPWR VPWR sky130_fd_sc_hd__decap_3
XFILLER_64_498 VGND VGND VPWR VPWR sky130_fd_sc_hd__fill_2
X_4952_ _4967_/B _4968_/A VGND VGND VPWR VPWR _4969_/C sky130_fd_sc_hd__or2b_2
XFILLER_60_660 VGND VGND VPWR VPWR sky130_fd_sc_hd__decap_3
X_3903_ _6782_/Q _3922_/A2 _3925_/A2 _6692_/Q _3902_/X VGND VGND VPWR VPWR _3904_/B
+ sky130_fd_sc_hd__a221o_2
XFILLER_20_524 VGND VGND VPWR VPWR sky130_fd_sc_hd__decap_3
XFILLER_32_373 VGND VGND VPWR VPWR sky130_fd_sc_hd__decap_3
XFILLER_60_693 VGND VGND VPWR VPWR sky130_fd_sc_hd__decap_3
X_6622_ _6622_/A VGND VGND VPWR VPWR _6622_/Y sky130_fd_sc_hd__inv_2
XFILLER_32_395 VGND VGND VPWR VPWR sky130_fd_sc_hd__fill_1
XFILLER_20_568 VGND VGND VPWR VPWR sky130_fd_sc_hd__decap_3
X_6553_ _6554_/A VGND VGND VPWR VPWR _6553_/Y sky130_fd_sc_hd__inv_2
X_3765_ _3629_/Y _3764_/X _4770_/A1 VGND VGND VPWR VPWR _4927_/B sky130_fd_sc_hd__o21a_2
XFILLER_106_607 VGND VGND VPWR VPWR sky130_fd_sc_hd__decap_3
X_6484_ _6676_/A VGND VGND VPWR VPWR _6484_/Y sky130_fd_sc_hd__inv_2
X_3696_ _6940_/Q _3760_/A2 _3759_/A2 _6804_/Q _3695_/X VGND VGND VPWR VPWR _3696_/X
+ sky130_fd_sc_hd__a221o_2
XTAP_TAPCELL_ROW_76_1204 VGND VPWR sky130_fd_sc_hd__tapvpwrvgnd_1
XFILLER_9_591 VGND VGND VPWR VPWR sky130_fd_sc_hd__decap_3
XFILLER_10_27 VGND VGND VPWR VPWR sky130_fd_sc_hd__fill_1
XFILLER_10_38 VGND VGND VPWR VPWR sky130_fd_sc_hd__fill_1
XFILLER_114_640 VGND VGND VPWR VPWR sky130_fd_sc_hd__decap_3
XFILLER_114_651 VGND VGND VPWR VPWR sky130_fd_sc_hd__decap_3
XFILLER_99_351 VGND VGND VPWR VPWR sky130_fd_sc_hd__decap_3
XFILLER_99_340 VGND VGND VPWR VPWR sky130_fd_sc_hd__decap_3
XFILLER_101_301 VGND VGND VPWR VPWR sky130_fd_sc_hd__decap_3
XFILLER_113_183 VGND VGND VPWR VPWR sky130_fd_sc_hd__fill_2
XFILLER_114_684 VGND VGND VPWR VPWR sky130_fd_sc_hd__decap_3
X_7105_ _7370_/CLK _7105_/D _6385_/Y VGND VGND VPWR VPWR _7105_/Q sky130_fd_sc_hd__dfrtp_2
X_4317_ _7322_/Q _3975_/S _4338_/B1 _7354_/Q _4347_/C1 VGND VGND VPWR VPWR _4317_/X
+ sky130_fd_sc_hd__a221o_2
XFILLER_99_373 VGND VGND VPWR VPWR sky130_fd_sc_hd__decap_3
X_7036_ _7387_/CLK _7036_/D _6316_/Y VGND VGND VPWR VPWR _7036_/Q sky130_fd_sc_hd__dfrtp_2
X_4248_ _4248_/A _4248_/B _4248_/C VGND VGND VPWR VPWR _4626_/B sky130_fd_sc_hd__or3_4
XFILLER_101_367 VGND VGND VPWR VPWR sky130_fd_sc_hd__decap_3
XFILLER_101_389 VGND VGND VPWR VPWR sky130_fd_sc_hd__decap_3
XFILLER_28_613 VGND VGND VPWR VPWR sky130_fd_sc_hd__decap_3
XFILLER_27_134 VGND VGND VPWR VPWR sky130_fd_sc_hd__decap_3
XFILLER_28_657 VGND VGND VPWR VPWR sky130_fd_sc_hd__decap_3
XFILLER_55_432 VGND VGND VPWR VPWR sky130_fd_sc_hd__decap_3
XFILLER_67_281 VGND VGND VPWR VPWR sky130_fd_sc_hd__decap_3
X_4179_ _4173_/Y _4248_/A _4376_/A _4178_/Y VGND VGND VPWR VPWR _4186_/A sky130_fd_sc_hd__a211o_2
XTAP_TAPCELL_ROW_87_1344 VGND VPWR sky130_fd_sc_hd__tapvpwrvgnd_1
XFILLER_27_167 VGND VGND VPWR VPWR sky130_fd_sc_hd__fill_1
XTAP_TAPCELL_ROW_2_288 VGND VPWR sky130_fd_sc_hd__tapvpwrvgnd_1
XTAP_TAPCELL_ROW_2_277 VGND VPWR sky130_fd_sc_hd__tapvpwrvgnd_1
XFILLER_27_178 VGND VGND VPWR VPWR sky130_fd_sc_hd__decap_3
XFILLER_35_46 VGND VGND VPWR VPWR sky130_fd_sc_hd__decap_3
XFILLER_35_57 VGND VGND VPWR VPWR sky130_fd_sc_hd__decap_3
XFILLER_36_690 VGND VGND VPWR VPWR sky130_fd_sc_hd__decap_3
XFILLER_42_104 VGND VGND VPWR VPWR sky130_fd_sc_hd__decap_3
XFILLER_43_638 VGND VGND VPWR VPWR sky130_fd_sc_hd__decap_3
XFILLER_70_424 VGND VGND VPWR VPWR sky130_fd_sc_hd__decap_3
XFILLER_82_273 VGND VGND VPWR VPWR sky130_fd_sc_hd__decap_3
XFILLER_23_340 VGND VGND VPWR VPWR sky130_fd_sc_hd__decap_3
XFILLER_42_137 VGND VGND VPWR VPWR sky130_fd_sc_hd__decap_3
XFILLER_23_384 VGND VGND VPWR VPWR sky130_fd_sc_hd__fill_1
XFILLER_51_671 VGND VGND VPWR VPWR sky130_fd_sc_hd__fill_1
XFILLER_51_682 VGND VGND VPWR VPWR sky130_fd_sc_hd__decap_3
XFILLER_50_170 VGND VGND VPWR VPWR sky130_fd_sc_hd__decap_3
Xclkbuf_3_3__f_clk clkbuf_0_clk/X VGND VGND VPWR VPWR clkload0/A sky130_fd_sc_hd__clkbuf_16
XPHY_EDGE_ROW_14_Right_14 VGND VGND VPWR VPWR sky130_fd_sc_hd__decap_3
XFILLER_11_579 VGND VGND VPWR VPWR sky130_fd_sc_hd__decap_3
XFILLER_7_517 VGND VGND VPWR VPWR sky130_fd_sc_hd__decap_3
XFILLER_3_712 VGND VGND VPWR VPWR sky130_fd_sc_hd__fill_2
XTAP_TAPCELL_ROW_98_1484 VGND VPWR sky130_fd_sc_hd__tapvpwrvgnd_1
XFILLER_2_200 VGND VGND VPWR VPWR sky130_fd_sc_hd__decap_3
XFILLER_105_662 VGND VGND VPWR VPWR sky130_fd_sc_hd__decap_3
XFILLER_105_673 VGND VGND VPWR VPWR sky130_fd_sc_hd__decap_3
XFILLER_2_244 VGND VGND VPWR VPWR sky130_fd_sc_hd__decap_3
XFILLER_78_502 VGND VGND VPWR VPWR sky130_fd_sc_hd__decap_3
XFILLER_104_150 VGND VGND VPWR VPWR sky130_fd_sc_hd__decap_3
XFILLER_104_183 VGND VGND VPWR VPWR sky130_fd_sc_hd__decap_3
XFILLER_2_288 VGND VGND VPWR VPWR sky130_fd_sc_hd__fill_2
XFILLER_2_299 VGND VGND VPWR VPWR sky130_fd_sc_hd__decap_3
XPHY_EDGE_ROW_23_Right_23 VGND VGND VPWR VPWR sky130_fd_sc_hd__decap_3
XFILLER_116_71 VGND VGND VPWR VPWR sky130_fd_sc_hd__decap_3
XFILLER_78_568 VGND VGND VPWR VPWR sky130_fd_sc_hd__decap_3
XFILLER_19_613 VGND VGND VPWR VPWR sky130_fd_sc_hd__decap_3
XFILLER_18_112 VGND VGND VPWR VPWR sky130_fd_sc_hd__decap_3
XFILLER_19_635 VGND VGND VPWR VPWR sky130_fd_sc_hd__decap_3
XFILLER_46_410 VGND VGND VPWR VPWR sky130_fd_sc_hd__decap_3
XFILLER_46_421 VGND VGND VPWR VPWR sky130_fd_sc_hd__fill_1
XFILLER_46_432 VGND VGND VPWR VPWR sky130_fd_sc_hd__decap_3
XFILLER_58_281 VGND VGND VPWR VPWR sky130_fd_sc_hd__decap_3
XFILLER_76_97 VGND VGND VPWR VPWR sky130_fd_sc_hd__decap_3
XFILLER_19_668 VGND VGND VPWR VPWR sky130_fd_sc_hd__decap_3
XFILLER_19_679 VGND VGND VPWR VPWR sky130_fd_sc_hd__decap_3
XFILLER_34_616 VGND VGND VPWR VPWR sky130_fd_sc_hd__decap_3
XFILLER_46_465 VGND VGND VPWR VPWR sky130_fd_sc_hd__decap_3
XFILLER_61_402 VGND VGND VPWR VPWR sky130_fd_sc_hd__fill_1
XFILLER_73_262 VGND VGND VPWR VPWR sky130_fd_sc_hd__decap_3
XTAP_TAPCELL_ROW_57_972 VGND VPWR sky130_fd_sc_hd__tapvpwrvgnd_1
XFILLER_73_284 VGND VGND VPWR VPWR sky130_fd_sc_hd__decap_3
XFILLER_73_295 VGND VGND VPWR VPWR sky130_fd_sc_hd__decap_3
XFILLER_92_63 VGND VGND VPWR VPWR sky130_fd_sc_hd__decap_3
XFILLER_14_340 VGND VGND VPWR VPWR sky130_fd_sc_hd__decap_3
XFILLER_61_457 VGND VGND VPWR VPWR sky130_fd_sc_hd__decap_3
XFILLER_92_85 VGND VGND VPWR VPWR sky130_fd_sc_hd__decap_3
XTAP_TAPCELL_ROW_107_1591 VGND VPWR sky130_fd_sc_hd__tapvpwrvgnd_1
XPHY_EDGE_ROW_32_Right_32 VGND VGND VPWR VPWR sky130_fd_sc_hd__decap_3
XFILLER_25_90 VGND VGND VPWR VPWR sky130_fd_sc_hd__decap_3
XFILLER_42_660 VGND VGND VPWR VPWR sky130_fd_sc_hd__decap_3
XTAP_TAPCELL_ROW_60_1005 VGND VPWR sky130_fd_sc_hd__tapvpwrvgnd_1
XFILLER_42_693 VGND VGND VPWR VPWR sky130_fd_sc_hd__decap_3
X_3550_ _4614_/A _3547_/A _3547_/B _3548_/X VGND VGND VPWR VPWR _3550_/X sky130_fd_sc_hd__a31o_2
XFILLER_115_415 VGND VGND VPWR VPWR sky130_fd_sc_hd__fill_2
XFILLER_6_572 VGND VGND VPWR VPWR sky130_fd_sc_hd__decap_3
X_3481_ _7344_/Q _4337_/B _5159_/S _7280_/Q VGND VGND VPWR VPWR _3482_/C sky130_fd_sc_hd__a22o_2
XFILLER_102_109 VGND VGND VPWR VPWR sky130_fd_sc_hd__decap_3
XFILLER_44_3 VGND VGND VPWR VPWR sky130_fd_sc_hd__decap_3
XPHY_EDGE_ROW_41_Right_41 VGND VGND VPWR VPWR sky130_fd_sc_hd__decap_3
X_5151_ _5151_/A _5659_/B VGND VGND VPWR VPWR _5151_/X sky130_fd_sc_hd__or2_2
XTAP_TAPCELL_ROW_71_1145 VGND VPWR sky130_fd_sc_hd__tapvpwrvgnd_1
XFILLER_111_632 VGND VGND VPWR VPWR sky130_fd_sc_hd__decap_3
XFILLER_111_665 VGND VGND VPWR VPWR sky130_fd_sc_hd__decap_3
X_5082_ _6986_/Q _5098_/A VGND VGND VPWR VPWR _6986_/D sky130_fd_sc_hd__xor2_2
X_4102_ _7077_/Q _4102_/B VGND VGND VPWR VPWR _4141_/B sky130_fd_sc_hd__nor2_2
XFILLER_111_676 VGND VGND VPWR VPWR sky130_fd_sc_hd__decap_3
XFILLER_96_365 VGND VGND VPWR VPWR sky130_fd_sc_hd__decap_3
XFILLER_96_398 VGND VGND VPWR VPWR sky130_fd_sc_hd__decap_3
X_4033_ _7054_/Q _4488_/S _4181_/B1 _7406_/Q VGND VGND VPWR VPWR _4033_/X sky130_fd_sc_hd__a22o_2
XPHY_EDGE_ROW_16_Left_136 VGND VGND VPWR VPWR sky130_fd_sc_hd__decap_3
XFILLER_110_186 VGND VGND VPWR VPWR sky130_fd_sc_hd__decap_3
XFILLER_110_197 VGND VGND VPWR VPWR sky130_fd_sc_hd__decap_3
XFILLER_49_281 VGND VGND VPWR VPWR sky130_fd_sc_hd__decap_3
XFILLER_112_18 VGND VGND VPWR VPWR sky130_fd_sc_hd__decap_3
XFILLER_112_29 VGND VGND VPWR VPWR sky130_fd_sc_hd__decap_3
XFILLER_18_690 VGND VGND VPWR VPWR sky130_fd_sc_hd__decap_3
XFILLER_25_638 VGND VGND VPWR VPWR sky130_fd_sc_hd__decap_3
XFILLER_52_424 VGND VGND VPWR VPWR sky130_fd_sc_hd__fill_1
XFILLER_64_295 VGND VGND VPWR VPWR sky130_fd_sc_hd__decap_3
XPHY_EDGE_ROW_50_Right_50 VGND VGND VPWR VPWR sky130_fd_sc_hd__decap_3
XFILLER_24_159 VGND VGND VPWR VPWR sky130_fd_sc_hd__decap_3
XFILLER_33_671 VGND VGND VPWR VPWR sky130_fd_sc_hd__fill_1
XFILLER_33_682 VGND VGND VPWR VPWR sky130_fd_sc_hd__decap_3
XFILLER_40_619 VGND VGND VPWR VPWR sky130_fd_sc_hd__decap_3
X_4935_ _6995_/Q _4963_/A VGND VGND VPWR VPWR _6995_/D sky130_fd_sc_hd__xor2_2
XTAP_TAPCELL_ROW_35_699 VGND VPWR sky130_fd_sc_hd__tapvpwrvgnd_1
XFILLER_20_321 VGND VGND VPWR VPWR sky130_fd_sc_hd__decap_3
XTAP_TAPCELL_ROW_82_1285 VGND VPWR sky130_fd_sc_hd__tapvpwrvgnd_1
XPHY_EDGE_ROW_25_Left_145 VGND VGND VPWR VPWR sky130_fd_sc_hd__decap_3
XFILLER_20_343 VGND VGND VPWR VPWR sky130_fd_sc_hd__decap_3
XFILLER_20_365 VGND VGND VPWR VPWR sky130_fd_sc_hd__decap_3
X_6605_ _6637_/A VGND VGND VPWR VPWR _6605_/Y sky130_fd_sc_hd__inv_2
X_4797_ _4970_/A1 _4648_/A _4795_/A _5033_/B2 VGND VGND VPWR VPWR _4797_/X sky130_fd_sc_hd__a22o_2
X_3817_ _3682_/A _3816_/X _4791_/A1 VGND VGND VPWR VPWR _3817_/X sky130_fd_sc_hd__a21o_2
X_6536_ _6637_/A VGND VGND VPWR VPWR _6536_/Y sky130_fd_sc_hd__inv_2
X_3748_ _3735_/X _3738_/X _3740_/X _3629_/A _3747_/X VGND VGND VPWR VPWR _3748_/X
+ sky130_fd_sc_hd__a221o_2
XFILLER_106_404 VGND VGND VPWR VPWR sky130_fd_sc_hd__decap_3
XFILLER_115_9 VGND VGND VPWR VPWR sky130_fd_sc_hd__decap_3
X_6467_ _6625_/A VGND VGND VPWR VPWR _6467_/Y sky130_fd_sc_hd__inv_2
X_3679_ _6894_/Q VGND VGND VPWR VPWR _3679_/Y sky130_fd_sc_hd__inv_2
XFILLER_0_704 VGND VGND VPWR VPWR sky130_fd_sc_hd__fill_2
X_6398_ _6653_/A VGND VGND VPWR VPWR _6398_/Y sky130_fd_sc_hd__inv_2
XFILLER_114_481 VGND VGND VPWR VPWR sky130_fd_sc_hd__fill_2
XTAP_TAPCELL_ROW_7_347 VGND VPWR sky130_fd_sc_hd__tapvpwrvgnd_1
XFILLER_102_643 VGND VGND VPWR VPWR sky130_fd_sc_hd__fill_1
XFILLER_102_654 VGND VGND VPWR VPWR sky130_fd_sc_hd__decap_3
XFILLER_87_343 VGND VGND VPWR VPWR sky130_fd_sc_hd__decap_3
XPHY_EDGE_ROW_34_Left_154 VGND VGND VPWR VPWR sky130_fd_sc_hd__decap_3
XFILLER_101_164 VGND VGND VPWR VPWR sky130_fd_sc_hd__decap_3
XFILLER_102_687 VGND VGND VPWR VPWR sky130_fd_sc_hd__decap_3
XFILLER_75_516 VGND VGND VPWR VPWR sky130_fd_sc_hd__fill_1
XFILLER_101_175 VGND VGND VPWR VPWR sky130_fd_sc_hd__decap_3
XFILLER_28_410 VGND VGND VPWR VPWR sky130_fd_sc_hd__decap_3
XFILLER_75_549 VGND VGND VPWR VPWR sky130_fd_sc_hd__decap_3
X_7019_ _7403_/CLK _7019_/D _6299_/Y VGND VGND VPWR VPWR _7019_/Q sky130_fd_sc_hd__dfrtp_2
XFILLER_16_616 VGND VGND VPWR VPWR sky130_fd_sc_hd__decap_3
XFILLER_71_700 VGND VGND VPWR VPWR sky130_fd_sc_hd__decap_3
XFILLER_90_519 VGND VGND VPWR VPWR sky130_fd_sc_hd__decap_3
XFILLER_43_402 VGND VGND VPWR VPWR sky130_fd_sc_hd__decap_3
XFILLER_46_78 VGND VGND VPWR VPWR sky130_fd_sc_hd__decap_3
XFILLER_55_273 VGND VGND VPWR VPWR sky130_fd_sc_hd__decap_3
XFILLER_55_284 VGND VGND VPWR VPWR sky130_fd_sc_hd__decap_3
XTAP_TAPCELL_ROW_54_931 VGND VPWR sky130_fd_sc_hd__tapvpwrvgnd_1
XFILLER_15_159 VGND VGND VPWR VPWR sky130_fd_sc_hd__fill_2
XFILLER_70_221 VGND VGND VPWR VPWR sky130_fd_sc_hd__decap_3
XFILLER_24_660 VGND VGND VPWR VPWR sky130_fd_sc_hd__decap_3
XFILLER_43_479 VGND VGND VPWR VPWR sky130_fd_sc_hd__decap_3
XPHY_EDGE_ROW_43_Left_163 VGND VGND VPWR VPWR sky130_fd_sc_hd__decap_3
XFILLER_11_310 VGND VGND VPWR VPWR sky130_fd_sc_hd__decap_3
XFILLER_11_332 VGND VGND VPWR VPWR sky130_fd_sc_hd__decap_3
XFILLER_23_181 VGND VGND VPWR VPWR sky130_fd_sc_hd__decap_3
XFILLER_24_693 VGND VGND VPWR VPWR sky130_fd_sc_hd__decap_3
XFILLER_7_314 VGND VGND VPWR VPWR sky130_fd_sc_hd__fill_1
XFILLER_109_220 VGND VGND VPWR VPWR sky130_fd_sc_hd__decap_3
XFILLER_109_231 VGND VGND VPWR VPWR sky130_fd_sc_hd__decap_3
XFILLER_11_376 VGND VGND VPWR VPWR sky130_fd_sc_hd__decap_3
XFILLER_109_275 VGND VGND VPWR VPWR sky130_fd_sc_hd__decap_3
XFILLER_3_520 VGND VGND VPWR VPWR sky130_fd_sc_hd__decap_3
XFILLER_3_553 VGND VGND VPWR VPWR sky130_fd_sc_hd__decap_3
XFILLER_3_564 VGND VGND VPWR VPWR sky130_fd_sc_hd__decap_3
XFILLER_3_597 VGND VGND VPWR VPWR sky130_fd_sc_hd__decap_3
XPHY_EDGE_ROW_52_Left_172 VGND VGND VPWR VPWR sky130_fd_sc_hd__decap_3
XFILLER_105_492 VGND VGND VPWR VPWR sky130_fd_sc_hd__decap_3
XFILLER_78_321 VGND VGND VPWR VPWR sky130_fd_sc_hd__fill_2
XFILLER_78_365 VGND VGND VPWR VPWR sky130_fd_sc_hd__fill_2
XFILLER_78_387 VGND VGND VPWR VPWR sky130_fd_sc_hd__decap_3
XFILLER_93_302 VGND VGND VPWR VPWR sky130_fd_sc_hd__decap_3
XFILLER_93_346 VGND VGND VPWR VPWR sky130_fd_sc_hd__decap_3
XTAP_TAPCELL_ROW_109_1620 VGND VPWR sky130_fd_sc_hd__tapvpwrvgnd_1
XFILLER_46_251 VGND VGND VPWR VPWR sky130_fd_sc_hd__fill_1
XFILLER_19_476 VGND VGND VPWR VPWR sky130_fd_sc_hd__decap_3
XFILLER_34_424 VGND VGND VPWR VPWR sky130_fd_sc_hd__fill_2
XFILLER_61_210 VGND VGND VPWR VPWR sky130_fd_sc_hd__decap_3
XFILLER_46_295 VGND VGND VPWR VPWR sky130_fd_sc_hd__decap_3
XPHY_EDGE_ROW_61_Left_181 VGND VGND VPWR VPWR sky130_fd_sc_hd__decap_3
XFILLER_15_671 VGND VGND VPWR VPWR sky130_fd_sc_hd__fill_1
XFILLER_15_682 VGND VGND VPWR VPWR sky130_fd_sc_hd__decap_3
XFILLER_22_619 VGND VGND VPWR VPWR sky130_fd_sc_hd__decap_3
XFILLER_14_181 VGND VGND VPWR VPWR sky130_fd_sc_hd__decap_3
Xclkbuf_leaf_41_clk clkbuf_leaf_6_clk/A VGND VGND VPWR VPWR _7189_/CLK sky130_fd_sc_hd__clkbuf_16
X_4720_ _4720_/A _4720_/B VGND VGND VPWR VPWR _4720_/X sky130_fd_sc_hd__xor2_2
XFILLER_30_663 VGND VGND VPWR VPWR sky130_fd_sc_hd__decap_3
X_4651_ _4813_/A _4810_/B VGND VGND VPWR VPWR _4652_/B sky130_fd_sc_hd__and2_2
XTAP_TAPCELL_ROW_32_658 VGND VPWR sky130_fd_sc_hd__tapvpwrvgnd_1
XFILLER_30_696 VGND VGND VPWR VPWR sky130_fd_sc_hd__decap_3
X_3602_ _4614_/A _3547_/A _3547_/B _4614_/C _4613_/B VGND VGND VPWR VPWR _3603_/B
+ sky130_fd_sc_hd__a41o_2
XFILLER_116_713 VGND VGND VPWR VPWR sky130_fd_sc_hd__fill_1
X_7370_ _7370_/CLK _7370_/D _6650_/Y VGND VGND VPWR VPWR _7370_/Q sky130_fd_sc_hd__dfrtp_2
XFILLER_115_223 VGND VGND VPWR VPWR sky130_fd_sc_hd__fill_1
Xhold804 _6837_/Q VGND VGND VPWR VPWR _6837_/D sky130_fd_sc_hd__dlygate4sd3_1
Xhold815 _6772_/Q VGND VGND VPWR VPWR _6772_/D sky130_fd_sc_hd__dlygate4sd3_1
Xhold826 _6804_/Q VGND VGND VPWR VPWR _6804_/D sky130_fd_sc_hd__dlygate4sd3_1
Xhold837 _6830_/Q VGND VGND VPWR VPWR _6830_/D sky130_fd_sc_hd__dlygate4sd3_1
X_6321_ _6672_/A VGND VGND VPWR VPWR _6321_/Y sky130_fd_sc_hd__inv_2
XFILLER_107_18 VGND VGND VPWR VPWR sky130_fd_sc_hd__decap_3
XFILLER_6_391 VGND VGND VPWR VPWR sky130_fd_sc_hd__fill_2
Xhold848 _6720_/Q VGND VGND VPWR VPWR _6720_/D sky130_fd_sc_hd__dlygate4sd3_1
Xhold859 _6862_/Q VGND VGND VPWR VPWR _6862_/D sky130_fd_sc_hd__dlygate4sd3_1
XPHY_EDGE_ROW_70_Left_190 VGND VGND VPWR VPWR sky130_fd_sc_hd__decap_3
XFILLER_103_429 VGND VGND VPWR VPWR sky130_fd_sc_hd__decap_3
XFILLER_88_129 VGND VGND VPWR VPWR sky130_fd_sc_hd__decap_3
X_5203_ _5203_/A _5225_/B VGND VGND VPWR VPWR _7227_/D sky130_fd_sc_hd__and2_2
XFILLER_97_641 VGND VGND VPWR VPWR sky130_fd_sc_hd__decap_3
X_5134_ _3735_/A _3908_/X _3346_/A VGND VGND VPWR VPWR _5134_/X sky130_fd_sc_hd__o21a_2
X_3395_ _7059_/Q _3558_/B VGND VGND VPWR VPWR _3589_/B sky130_fd_sc_hd__nor2_2
XTAP_TAPCELL_ROW_4_306 VGND VPWR sky130_fd_sc_hd__tapvpwrvgnd_1
XFILLER_57_505 VGND VGND VPWR VPWR sky130_fd_sc_hd__decap_3
XFILLER_69_376 VGND VGND VPWR VPWR sky130_fd_sc_hd__decap_3
XFILLER_84_313 VGND VGND VPWR VPWR sky130_fd_sc_hd__decap_3
XFILLER_96_162 VGND VGND VPWR VPWR sky130_fd_sc_hd__decap_3
XFILLER_97_685 VGND VGND VPWR VPWR sky130_fd_sc_hd__decap_3
XFILLER_84_335 VGND VGND VPWR VPWR sky130_fd_sc_hd__decap_3
XFILLER_96_195 VGND VGND VPWR VPWR sky130_fd_sc_hd__fill_1
X_5065_ _6986_/Q _5098_/A _6987_/Q VGND VGND VPWR VPWR _5066_/B sky130_fd_sc_hd__a21oi_2
XFILLER_37_251 VGND VGND VPWR VPWR sky130_fd_sc_hd__decap_3
XFILLER_53_700 VGND VGND VPWR VPWR sky130_fd_sc_hd__decap_3
XFILLER_84_368 VGND VGND VPWR VPWR sky130_fd_sc_hd__decap_3
XTAP_TAPCELL_ROW_84_1314 VGND VPWR sky130_fd_sc_hd__tapvpwrvgnd_1
XTAP_TAPCELL_ROW_84_1303 VGND VPWR sky130_fd_sc_hd__tapvpwrvgnd_1
XFILLER_37_295 VGND VGND VPWR VPWR sky130_fd_sc_hd__decap_3
XFILLER_52_221 VGND VGND VPWR VPWR sky130_fd_sc_hd__decap_3
XTAP_TAPCELL_ROW_51_901 VGND VPWR sky130_fd_sc_hd__tapvpwrvgnd_1
Xclkbuf_leaf_32_clk clkbuf_3_2__f_clk/X VGND VGND VPWR VPWR _7313_/CLK sky130_fd_sc_hd__clkbuf_16
X_4918_ _4918_/A _4918_/B VGND VGND VPWR VPWR _4936_/B sky130_fd_sc_hd__nor2_2
XFILLER_21_641 VGND VGND VPWR VPWR sky130_fd_sc_hd__decap_3
XFILLER_21_685 VGND VGND VPWR VPWR sky130_fd_sc_hd__decap_3
X_4849_ _4872_/A _4872_/B VGND VGND VPWR VPWR _4849_/Y sky130_fd_sc_hd__nor2_2
XFILLER_119_551 VGND VGND VPWR VPWR sky130_fd_sc_hd__decap_3
XFILLER_119_573 VGND VGND VPWR VPWR sky130_fd_sc_hd__decap_3
XFILLER_20_195 VGND VGND VPWR VPWR sky130_fd_sc_hd__fill_1
XFILLER_4_306 VGND VGND VPWR VPWR sky130_fd_sc_hd__fill_2
XFILLER_113_6 VGND VGND VPWR VPWR sky130_fd_sc_hd__decap_3
X_6519_ _6651_/A VGND VGND VPWR VPWR _6519_/Y sky130_fd_sc_hd__inv_2
XTAP_TAPCELL_ROW_95_1443 VGND VPWR sky130_fd_sc_hd__tapvpwrvgnd_1
XFILLER_106_256 VGND VGND VPWR VPWR sky130_fd_sc_hd__decap_3
XFILLER_0_501 VGND VGND VPWR VPWR sky130_fd_sc_hd__decap_3
XFILLER_88_630 VGND VGND VPWR VPWR sky130_fd_sc_hd__decap_3
XFILLER_102_473 VGND VGND VPWR VPWR sky130_fd_sc_hd__decap_3
XFILLER_87_140 VGND VGND VPWR VPWR sky130_fd_sc_hd__decap_3
XFILLER_87_162 VGND VGND VPWR VPWR sky130_fd_sc_hd__decap_3
XFILLER_88_663 VGND VGND VPWR VPWR sky130_fd_sc_hd__decap_3
XFILLER_88_696 VGND VGND VPWR VPWR sky130_fd_sc_hd__decap_3
XFILLER_57_66 VGND VGND VPWR VPWR sky130_fd_sc_hd__decap_3
XFILLER_87_184 VGND VGND VPWR VPWR sky130_fd_sc_hd__decap_3
XFILLER_57_99 VGND VGND VPWR VPWR sky130_fd_sc_hd__decap_3
XFILLER_63_508 VGND VGND VPWR VPWR sky130_fd_sc_hd__decap_3
XFILLER_113_50 VGND VGND VPWR VPWR sky130_fd_sc_hd__decap_3
XFILLER_113_72 VGND VGND VPWR VPWR sky130_fd_sc_hd__decap_3
XFILLER_16_402 VGND VGND VPWR VPWR sky130_fd_sc_hd__decap_3
XFILLER_90_327 VGND VGND VPWR VPWR sky130_fd_sc_hd__decap_3
Xplace508 _6981_/Q VGND VGND VPWR VPWR _3324_/A sky130_fd_sc_hd__buf_4
Xplace519 _6622_/A VGND VGND VPWR VPWR _6653_/A sky130_fd_sc_hd__buf_2
XFILLER_16_457 VGND VGND VPWR VPWR sky130_fd_sc_hd__decap_3
XFILLER_71_541 VGND VGND VPWR VPWR sky130_fd_sc_hd__decap_3
XFILLER_43_265 VGND VGND VPWR VPWR sky130_fd_sc_hd__decap_3
XFILLER_71_574 VGND VGND VPWR VPWR sky130_fd_sc_hd__decap_3
XTAP_TAPCELL_ROW_104_1561 VGND VPWR sky130_fd_sc_hd__tapvpwrvgnd_1
XFILLER_31_449 VGND VGND VPWR VPWR sky130_fd_sc_hd__decap_3
Xclkbuf_leaf_23_clk clkbuf_3_6__f_clk/X VGND VGND VPWR VPWR _7370_/CLK sky130_fd_sc_hd__clkbuf_16
XFILLER_11_140 VGND VGND VPWR VPWR sky130_fd_sc_hd__decap_3
XFILLER_12_663 VGND VGND VPWR VPWR sky130_fd_sc_hd__decap_3
XFILLER_8_601 VGND VGND VPWR VPWR sky130_fd_sc_hd__decap_3
XFILLER_12_696 VGND VGND VPWR VPWR sky130_fd_sc_hd__decap_3
XFILLER_8_634 VGND VGND VPWR VPWR sky130_fd_sc_hd__decap_3
XFILLER_8_645 VGND VGND VPWR VPWR sky130_fd_sc_hd__decap_3
XFILLER_7_144 VGND VGND VPWR VPWR sky130_fd_sc_hd__decap_3
XFILLER_8_678 VGND VGND VPWR VPWR sky130_fd_sc_hd__decap_3
XFILLER_22_91 VGND VGND VPWR VPWR sky130_fd_sc_hd__fill_1
XFILLER_3_361 VGND VGND VPWR VPWR sky130_fd_sc_hd__decap_3
XFILLER_98_427 VGND VGND VPWR VPWR sky130_fd_sc_hd__decap_3
XTAP_TAPCELL_ROW_115_1690 VGND VPWR sky130_fd_sc_hd__tapvpwrvgnd_1
XFILLER_112_248 VGND VGND VPWR VPWR sky130_fd_sc_hd__decap_3
XFILLER_112_259 VGND VGND VPWR VPWR sky130_fd_sc_hd__fill_1
XFILLER_79_641 VGND VGND VPWR VPWR sky130_fd_sc_hd__decap_3
XFILLER_79_685 VGND VGND VPWR VPWR sky130_fd_sc_hd__decap_3
XFILLER_78_184 VGND VGND VPWR VPWR sky130_fd_sc_hd__decap_3
XFILLER_94_622 VGND VGND VPWR VPWR sky130_fd_sc_hd__decap_3
XFILLER_93_143 VGND VGND VPWR VPWR sky130_fd_sc_hd__decap_3
XFILLER_94_666 VGND VGND VPWR VPWR sky130_fd_sc_hd__decap_3
XFILLER_19_262 VGND VGND VPWR VPWR sky130_fd_sc_hd__decap_3
XFILLER_19_284 VGND VGND VPWR VPWR sky130_fd_sc_hd__decap_3
XFILLER_35_700 VGND VGND VPWR VPWR sky130_fd_sc_hd__decap_3
XFILLER_81_316 VGND VGND VPWR VPWR sky130_fd_sc_hd__decap_3
XFILLER_93_165 VGND VGND VPWR VPWR sky130_fd_sc_hd__decap_3
XFILLER_93_187 VGND VGND VPWR VPWR sky130_fd_sc_hd__decap_3
XFILLER_94_699 VGND VGND VPWR VPWR sky130_fd_sc_hd__fill_1
XTAP_TAPCELL_ROW_37_717 VGND VPWR sky130_fd_sc_hd__tapvpwrvgnd_1
XFILLER_34_232 VGND VGND VPWR VPWR sky130_fd_sc_hd__decap_3
XFILLER_81_349 VGND VGND VPWR VPWR sky130_fd_sc_hd__decap_3
X_6870_ clkload8/A _6870_/D VGND VGND VPWR VPWR _6870_/Q sky130_fd_sc_hd__dfxtp_2
XFILLER_22_405 VGND VGND VPWR VPWR sky130_fd_sc_hd__decap_3
XFILLER_34_265 VGND VGND VPWR VPWR sky130_fd_sc_hd__fill_1
XFILLER_62_563 VGND VGND VPWR VPWR sky130_fd_sc_hd__decap_3
XTAP_TAPCELL_ROW_66_1077 VGND VPWR sky130_fd_sc_hd__tapvpwrvgnd_1
XFILLER_22_427 VGND VGND VPWR VPWR sky130_fd_sc_hd__decap_3
XFILLER_34_298 VGND VGND VPWR VPWR sky130_fd_sc_hd__decap_3
XTAP_TAPCELL_ROW_66_1088 VGND VPWR sky130_fd_sc_hd__tapvpwrvgnd_1
XTAP_TAPCELL_ROW_17_474 VGND VPWR sky130_fd_sc_hd__tapvpwrvgnd_1
Xclkbuf_leaf_14_clk clkload1/A VGND VGND VPWR VPWR _7406_/CLK sky130_fd_sc_hd__clkbuf_16
X_4703_ _6992_/Q _6993_/Q _5001_/A VGND VGND VPWR VPWR _4977_/A sky130_fd_sc_hd__and3_2
X_4634_ _4937_/A _4920_/A _4967_/B _4950_/A VGND VGND VPWR VPWR _4634_/Y sky130_fd_sc_hd__nand4bb_2
X_7353_ _7354_/CLK _7353_/D _6633_/Y VGND VGND VPWR VPWR _7353_/Q sky130_fd_sc_hd__dfrtp_2
X_4565_ _4565_/A _4577_/B VGND VGND VPWR VPWR _7298_/D sky130_fd_sc_hd__and2_2
XFILLER_116_565 VGND VGND VPWR VPWR sky130_fd_sc_hd__fill_2
X_6304_ _6647_/A VGND VGND VPWR VPWR _6304_/Y sky130_fd_sc_hd__inv_2
X_3516_ _5118_/A _6979_/Q _5118_/D _3371_/A VGND VGND VPWR VPWR _3516_/X sky130_fd_sc_hd__a211o_2
XFILLER_116_576 VGND VGND VPWR VPWR sky130_fd_sc_hd__decap_3
XFILLER_116_598 VGND VGND VPWR VPWR sky130_fd_sc_hd__decap_3
XFILLER_89_427 VGND VGND VPWR VPWR sky130_fd_sc_hd__decap_3
X_7284_ _7313_/CLK _7284_/D _6564_/Y VGND VGND VPWR VPWR _7284_/Q sky130_fd_sc_hd__dfrtp_2
XPHY_EDGE_ROW_4_Right_4 VGND VGND VPWR VPWR sky130_fd_sc_hd__decap_3
XFILLER_89_449 VGND VGND VPWR VPWR sky130_fd_sc_hd__decap_3
Xhold689 _6884_/Q VGND VGND VPWR VPWR _6884_/D sky130_fd_sc_hd__dlygate4sd3_1
X_3447_ _7090_/Q _4351_/A2 _3407_/X _7122_/Q VGND VGND VPWR VPWR _3447_/X sky130_fd_sc_hd__a22o_2
XFILLER_57_302 VGND VGND VPWR VPWR sky130_fd_sc_hd__decap_3
XFILLER_85_611 VGND VGND VPWR VPWR sky130_fd_sc_hd__decap_3
XFILLER_97_471 VGND VGND VPWR VPWR sky130_fd_sc_hd__decap_3
X_3378_ _3378_/A _5646_/A VGND VGND VPWR VPWR _5229_/C sky130_fd_sc_hd__nor2_2
XTAP_TAPCELL_ROW_90_1384 VGND VPWR sky130_fd_sc_hd__tapvpwrvgnd_1
XFILLER_111_281 VGND VGND VPWR VPWR sky130_fd_sc_hd__decap_3
XFILLER_69_195 VGND VGND VPWR VPWR sky130_fd_sc_hd__decap_3
XFILLER_84_121 VGND VGND VPWR VPWR sky130_fd_sc_hd__decap_3
XFILLER_85_644 VGND VGND VPWR VPWR sky130_fd_sc_hd__decap_3
Xhold1301 _7378_/Q VGND VGND VPWR VPWR _3915_/A0 sky130_fd_sc_hd__dlygate4sd3_1
Xhold1312 _7329_/Q VGND VGND VPWR VPWR _4501_/A0 sky130_fd_sc_hd__dlygate4sd3_1
Xhold1323 _6692_/Q VGND VGND VPWR VPWR _5684_/A1 sky130_fd_sc_hd__dlygate4sd3_1
X_5117_ _5595_/B _5117_/B _3896_/Y VGND VGND VPWR VPWR _5117_/X sky130_fd_sc_hd__or3b_2
X_5048_ _5086_/A _5084_/B _4621_/X VGND VGND VPWR VPWR _5073_/B sky130_fd_sc_hd__o21bai_2
XFILLER_72_305 VGND VGND VPWR VPWR sky130_fd_sc_hd__decap_3
XFILLER_84_176 VGND VGND VPWR VPWR sky130_fd_sc_hd__decap_3
XFILLER_85_688 VGND VGND VPWR VPWR sky130_fd_sc_hd__decap_3
XFILLER_53_530 VGND VGND VPWR VPWR sky130_fd_sc_hd__fill_1
XFILLER_65_390 VGND VGND VPWR VPWR sky130_fd_sc_hd__fill_2
XFILLER_25_265 VGND VGND VPWR VPWR sky130_fd_sc_hd__decap_3
XFILLER_41_703 VGND VGND VPWR VPWR sky130_fd_sc_hd__decap_3
XFILLER_53_552 VGND VGND VPWR VPWR sky130_fd_sc_hd__decap_3
XFILLER_13_449 VGND VGND VPWR VPWR sky130_fd_sc_hd__decap_3
XFILLER_25_287 VGND VGND VPWR VPWR sky130_fd_sc_hd__decap_3
XFILLER_40_224 VGND VGND VPWR VPWR sky130_fd_sc_hd__decap_3
XFILLER_53_596 VGND VGND VPWR VPWR sky130_fd_sc_hd__fill_2
XFILLER_80_371 VGND VGND VPWR VPWR sky130_fd_sc_hd__fill_1
X_6999_ _7373_/CLK _6999_/D _6279_/Y VGND VGND VPWR VPWR _6999_/Q sky130_fd_sc_hd__dfrtp_2
XFILLER_40_268 VGND VGND VPWR VPWR sky130_fd_sc_hd__decap_3
XFILLER_43_57 VGND VGND VPWR VPWR sky130_fd_sc_hd__decap_3
XFILLER_111_3 VGND VGND VPWR VPWR sky130_fd_sc_hd__decap_3
XFILLER_119_381 VGND VGND VPWR VPWR sky130_fd_sc_hd__decap_3
XFILLER_5_615 VGND VGND VPWR VPWR sky130_fd_sc_hd__fill_1
XFILLER_5_626 VGND VGND VPWR VPWR sky130_fd_sc_hd__decap_3
XFILLER_5_659 VGND VGND VPWR VPWR sky130_fd_sc_hd__decap_3
XFILLER_107_598 VGND VGND VPWR VPWR sky130_fd_sc_hd__decap_3
XFILLER_108_50 VGND VGND VPWR VPWR sky130_fd_sc_hd__decap_3
XFILLER_4_29 VGND VGND VPWR VPWR sky130_fd_sc_hd__decap_3
XFILLER_95_408 VGND VGND VPWR VPWR sky130_fd_sc_hd__decap_3
XFILLER_76_633 VGND VGND VPWR VPWR sky130_fd_sc_hd__decap_3
XFILLER_102_292 VGND VGND VPWR VPWR sky130_fd_sc_hd__fill_1
XFILLER_48_368 VGND VGND VPWR VPWR sky130_fd_sc_hd__decap_3
XFILLER_75_132 VGND VGND VPWR VPWR sky130_fd_sc_hd__decap_3
XFILLER_76_666 VGND VGND VPWR VPWR sky130_fd_sc_hd__decap_3
XFILLER_17_700 VGND VGND VPWR VPWR sky130_fd_sc_hd__decap_3
XFILLER_29_582 VGND VGND VPWR VPWR sky130_fd_sc_hd__decap_3
XFILLER_63_316 VGND VGND VPWR VPWR sky130_fd_sc_hd__decap_3
XFILLER_75_165 VGND VGND VPWR VPWR sky130_fd_sc_hd__decap_3
XFILLER_75_187 VGND VGND VPWR VPWR sky130_fd_sc_hd__decap_3
XFILLER_76_699 VGND VGND VPWR VPWR sky130_fd_sc_hd__fill_1
XFILLER_84_75 VGND VGND VPWR VPWR sky130_fd_sc_hd__decap_3
XFILLER_84_97 VGND VGND VPWR VPWR sky130_fd_sc_hd__decap_3
XFILLER_90_124 VGND VGND VPWR VPWR sky130_fd_sc_hd__fill_1
XFILLER_91_647 VGND VGND VPWR VPWR sky130_fd_sc_hd__decap_3
Xplace327 _3665_/X VGND VGND VPWR VPWR _3911_/B1 sky130_fd_sc_hd__buf_2
XFILLER_16_265 VGND VGND VPWR VPWR sky130_fd_sc_hd__decap_3
Xplace349 _3879_/B1 VGND VGND VPWR VPWR _3913_/A2 sky130_fd_sc_hd__buf_2
Xplace338 _3656_/Y VGND VGND VPWR VPWR _3890_/B1 sky130_fd_sc_hd__buf_2
XFILLER_16_298 VGND VGND VPWR VPWR sky130_fd_sc_hd__fill_2
XFILLER_71_393 VGND VGND VPWR VPWR sky130_fd_sc_hd__decap_3
XFILLER_31_246 VGND VGND VPWR VPWR sky130_fd_sc_hd__decap_3
XTAP_TAPCELL_ROW_14_433 VGND VPWR sky130_fd_sc_hd__tapvpwrvgnd_1
XTAP_TAPCELL_ROW_42_786 VGND VPWR sky130_fd_sc_hd__tapvpwrvgnd_1
XFILLER_76_6 VGND VGND VPWR VPWR sky130_fd_sc_hd__decap_3
XFILLER_8_475 VGND VGND VPWR VPWR sky130_fd_sc_hd__fill_1
X_4350_ _7065_/Q _4305_/B _4460_/A VGND VGND VPWR VPWR _4367_/B sky130_fd_sc_hd__o21a_2
XFILLER_99_703 VGND VGND VPWR VPWR sky130_fd_sc_hd__decap_3
XFILLER_98_213 VGND VGND VPWR VPWR sky130_fd_sc_hd__decap_3
X_3301_ _6981_/Q _3327_/B VGND VGND VPWR VPWR _3519_/B sky130_fd_sc_hd__nand2_4
XFILLER_113_557 VGND VGND VPWR VPWR sky130_fd_sc_hd__decap_3
XFILLER_4_681 VGND VGND VPWR VPWR sky130_fd_sc_hd__decap_3
X_4281_ _7254_/Q _4599_/S _4278_/X _4280_/X VGND VGND VPWR VPWR _4281_/X sky130_fd_sc_hd__a211o_2
XFILLER_113_579 VGND VGND VPWR VPWR sky130_fd_sc_hd__decap_3
XFILLER_86_408 VGND VGND VPWR VPWR sky130_fd_sc_hd__decap_3
Xclkbuf_leaf_3_clk clkbuf_leaf_6_clk/A VGND VGND VPWR VPWR _6968_/CLK sky130_fd_sc_hd__clkbuf_16
XFILLER_39_302 VGND VGND VPWR VPWR sky130_fd_sc_hd__fill_1
XFILLER_39_313 VGND VGND VPWR VPWR sky130_fd_sc_hd__decap_3
XFILLER_66_110 VGND VGND VPWR VPWR sky130_fd_sc_hd__decap_3
XFILLER_67_644 VGND VGND VPWR VPWR sky130_fd_sc_hd__decap_3
XFILLER_79_482 VGND VGND VPWR VPWR sky130_fd_sc_hd__decap_3
XFILLER_104_19 VGND VGND VPWR VPWR sky130_fd_sc_hd__decap_3
XFILLER_27_508 VGND VGND VPWR VPWR sky130_fd_sc_hd__decap_3
XFILLER_39_357 VGND VGND VPWR VPWR sky130_fd_sc_hd__decap_3
XFILLER_66_121 VGND VGND VPWR VPWR sky130_fd_sc_hd__decap_3
XFILLER_94_430 VGND VGND VPWR VPWR sky130_fd_sc_hd__decap_3
XFILLER_94_452 VGND VGND VPWR VPWR sky130_fd_sc_hd__fill_1
XFILLER_39_379 VGND VGND VPWR VPWR sky130_fd_sc_hd__decap_3
XFILLER_67_688 VGND VGND VPWR VPWR sky130_fd_sc_hd__decap_3
XFILLER_81_113 VGND VGND VPWR VPWR sky130_fd_sc_hd__decap_3
XFILLER_82_625 VGND VGND VPWR VPWR sky130_fd_sc_hd__decap_3
XTAP_TAPCELL_ROW_68_1106 VGND VPWR sky130_fd_sc_hd__tapvpwrvgnd_1
XFILLER_35_530 VGND VGND VPWR VPWR sky130_fd_sc_hd__decap_3
XFILLER_81_146 VGND VGND VPWR VPWR sky130_fd_sc_hd__decap_3
XFILLER_82_669 VGND VGND VPWR VPWR sky130_fd_sc_hd__decap_3
X_6922_ _6922_/CLK _6922_/D VGND VGND VPWR VPWR _6922_/Q sky130_fd_sc_hd__dfxtp_2
XFILLER_23_703 VGND VGND VPWR VPWR sky130_fd_sc_hd__decap_3
XFILLER_81_179 VGND VGND VPWR VPWR sky130_fd_sc_hd__fill_1
X_6853_ clkload7/A _6853_/D VGND VGND VPWR VPWR _6853_/Q sky130_fd_sc_hd__dfxtp_2
XFILLER_22_213 VGND VGND VPWR VPWR sky130_fd_sc_hd__decap_3
XFILLER_35_585 VGND VGND VPWR VPWR sky130_fd_sc_hd__decap_3
XFILLER_50_522 VGND VGND VPWR VPWR sky130_fd_sc_hd__fill_1
XFILLER_22_268 VGND VGND VPWR VPWR sky130_fd_sc_hd__decap_3
X_6784_ _7189_/CLK _6784_/D VGND VGND VPWR VPWR _6784_/Q sky130_fd_sc_hd__dfxtp_2
X_3996_ _7344_/Q _4534_/A0 _3996_/S VGND VGND VPWR VPWR _7344_/D sky130_fd_sc_hd__mux2_2
XFILLER_10_419 VGND VGND VPWR VPWR sky130_fd_sc_hd__fill_1
X_5735_ _7373_/Q _5735_/A1 _5735_/S VGND VGND VPWR VPWR _6717_/D sky130_fd_sc_hd__mux2_2
X_5666_ _5666_/A _5666_/B VGND VGND VPWR VPWR _5668_/B sky130_fd_sc_hd__or2_2
X_7405_ _7406_/CLK _7405_/D _6685_/Y VGND VGND VPWR VPWR _7405_/Q sky130_fd_sc_hd__dfrtp_2
X_4617_ _5114_/B _4617_/B _4617_/C VGND VGND VPWR VPWR _5099_/A sky130_fd_sc_hd__or3_4
XTAP_TAPCELL_ROW_79_1246 VGND VPWR sky130_fd_sc_hd__tapvpwrvgnd_1
X_5597_ _5597_/A1 _5587_/B _5154_/Y VGND VGND VPWR VPWR _7029_/D sky130_fd_sc_hd__a21o_2
XTAP_TAPCELL_ROW_92_1402 VGND VPWR sky130_fd_sc_hd__tapvpwrvgnd_1
XFILLER_2_607 VGND VGND VPWR VPWR sky130_fd_sc_hd__decap_3
XFILLER_89_202 VGND VGND VPWR VPWR sky130_fd_sc_hd__decap_3
X_7336_ _7342_/CLK _7336_/D _6616_/Y VGND VGND VPWR VPWR _7336_/Q sky130_fd_sc_hd__dfrtp_2
X_4548_ _4548_/A _4563_/B VGND VGND VPWR VPWR _7306_/D sky130_fd_sc_hd__and2_2
XTAP_TAPCELL_ROW_92_1413 VGND VPWR sky130_fd_sc_hd__tapvpwrvgnd_1
X_7267_ _7342_/CLK _7267_/D _6547_/Y VGND VGND VPWR VPWR _7267_/Q sky130_fd_sc_hd__dfrtp_2
XPHY_EDGE_ROW_8_Left_128 VGND VGND VPWR VPWR sky130_fd_sc_hd__decap_3
XFILLER_104_579 VGND VGND VPWR VPWR sky130_fd_sc_hd__fill_1
XFILLER_77_408 VGND VGND VPWR VPWR sky130_fd_sc_hd__decap_3
XFILLER_89_268 VGND VGND VPWR VPWR sky130_fd_sc_hd__decap_3
XFILLER_38_24 VGND VGND VPWR VPWR sky130_fd_sc_hd__decap_3
XFILLER_58_622 VGND VGND VPWR VPWR sky130_fd_sc_hd__decap_3
X_7198_ _7358_/CLK _7198_/D _6478_/Y VGND VGND VPWR VPWR _7198_/Q sky130_fd_sc_hd__dfrtp_2
XFILLER_38_79 VGND VGND VPWR VPWR sky130_fd_sc_hd__decap_3
XFILLER_57_143 VGND VGND VPWR VPWR sky130_fd_sc_hd__decap_3
XFILLER_58_666 VGND VGND VPWR VPWR sky130_fd_sc_hd__decap_3
XFILLER_85_452 VGND VGND VPWR VPWR sky130_fd_sc_hd__decap_3
XFILLER_97_290 VGND VGND VPWR VPWR sky130_fd_sc_hd__decap_3
Xhold1120 _7375_/Q VGND VGND VPWR VPWR _3928_/A1 sky130_fd_sc_hd__dlygate4sd3_1
Xhold1131 _7189_/Q VGND VGND VPWR VPWR _5282_/A1 sky130_fd_sc_hd__dlygate4sd3_1
Xhold1142 _7212_/Q VGND VGND VPWR VPWR _5236_/A0 sky130_fd_sc_hd__dlygate4sd3_1
XFILLER_18_519 VGND VGND VPWR VPWR sky130_fd_sc_hd__fill_1
XFILLER_58_699 VGND VGND VPWR VPWR sky130_fd_sc_hd__fill_1
XFILLER_72_102 VGND VGND VPWR VPWR sky130_fd_sc_hd__decap_3
Xhold1153 _7233_/Q VGND VGND VPWR VPWR _5190_/A sky130_fd_sc_hd__dlygate4sd3_1
Xhold1164 _7209_/Q VGND VGND VPWR VPWR _5241_/A0 sky130_fd_sc_hd__dlygate4sd3_1
Xhold1175 _7256_/Q VGND VGND VPWR VPWR _5095_/A0 sky130_fd_sc_hd__dlygate4sd3_1
XPHY_EDGE_ROW_79_Right_79 VGND VGND VPWR VPWR sky130_fd_sc_hd__decap_3
XFILLER_45_349 VGND VGND VPWR VPWR sky130_fd_sc_hd__decap_3
XFILLER_73_647 VGND VGND VPWR VPWR sky130_fd_sc_hd__decap_3
Xhold1186 _7332_/Q VGND VGND VPWR VPWR _4495_/A0 sky130_fd_sc_hd__dlygate4sd3_1
Xhold1197 _7335_/Q VGND VGND VPWR VPWR _4488_/A0 sky130_fd_sc_hd__dlygate4sd3_1
XFILLER_13_202 VGND VGND VPWR VPWR sky130_fd_sc_hd__decap_3
XFILLER_26_585 VGND VGND VPWR VPWR sky130_fd_sc_hd__decap_3
XFILLER_53_393 VGND VGND VPWR VPWR sky130_fd_sc_hd__decap_3
XFILLER_81_691 VGND VGND VPWR VPWR sky130_fd_sc_hd__decap_3
XFILLER_110_62 VGND VGND VPWR VPWR sky130_fd_sc_hd__decap_3
XTAP_TAPCELL_ROW_101_1520 VGND VPWR sky130_fd_sc_hd__tapvpwrvgnd_1
XFILLER_41_588 VGND VGND VPWR VPWR sky130_fd_sc_hd__decap_3
XFILLER_70_88 VGND VGND VPWR VPWR sky130_fd_sc_hd__decap_3
XPHY_EDGE_ROW_88_Right_88 VGND VGND VPWR VPWR sky130_fd_sc_hd__decap_3
XFILLER_107_340 VGND VGND VPWR VPWR sky130_fd_sc_hd__decap_3
XFILLER_107_373 VGND VGND VPWR VPWR sky130_fd_sc_hd__fill_2
XFILLER_119_93 VGND VGND VPWR VPWR sky130_fd_sc_hd__decap_3
XFILLER_5_467 VGND VGND VPWR VPWR sky130_fd_sc_hd__decap_3
XFILLER_79_75 VGND VGND VPWR VPWR sky130_fd_sc_hd__decap_3
XFILLER_1_662 VGND VGND VPWR VPWR sky130_fd_sc_hd__decap_3
XTAP_TAPCELL_ROW_112_1660 VGND VPWR sky130_fd_sc_hd__tapvpwrvgnd_1
XFILLER_1_673 VGND VGND VPWR VPWR sky130_fd_sc_hd__decap_3
XFILLER_49_611 VGND VGND VPWR VPWR sky130_fd_sc_hd__decap_3
XFILLER_95_238 VGND VGND VPWR VPWR sky130_fd_sc_hd__decap_3
XFILLER_0_194 VGND VGND VPWR VPWR sky130_fd_sc_hd__fill_2
XFILLER_48_121 VGND VGND VPWR VPWR sky130_fd_sc_hd__decap_3
XFILLER_49_644 VGND VGND VPWR VPWR sky130_fd_sc_hd__decap_3
XFILLER_95_52 VGND VGND VPWR VPWR sky130_fd_sc_hd__decap_3
XFILLER_95_63 VGND VGND VPWR VPWR sky130_fd_sc_hd__decap_3
XPHY_EDGE_ROW_97_Right_97 VGND VGND VPWR VPWR sky130_fd_sc_hd__decap_3
XFILLER_36_305 VGND VGND VPWR VPWR sky130_fd_sc_hd__decap_3
XFILLER_49_688 VGND VGND VPWR VPWR sky130_fd_sc_hd__decap_3
XFILLER_63_102 VGND VGND VPWR VPWR sky130_fd_sc_hd__decap_3
XFILLER_64_625 VGND VGND VPWR VPWR sky130_fd_sc_hd__decap_3
XFILLER_76_474 VGND VGND VPWR VPWR sky130_fd_sc_hd__fill_2
XFILLER_28_90 VGND VGND VPWR VPWR sky130_fd_sc_hd__fill_2
XFILLER_48_187 VGND VGND VPWR VPWR sky130_fd_sc_hd__decap_3
XFILLER_63_113 VGND VGND VPWR VPWR sky130_fd_sc_hd__decap_3
XFILLER_64_669 VGND VGND VPWR VPWR sky130_fd_sc_hd__decap_3
XFILLER_91_433 VGND VGND VPWR VPWR sky130_fd_sc_hd__decap_3
XFILLER_91_455 VGND VGND VPWR VPWR sky130_fd_sc_hd__decap_3
XTAP_TAPCELL_ROW_47_845 VGND VPWR sky130_fd_sc_hd__tapvpwrvgnd_1
XFILLER_17_552 VGND VGND VPWR VPWR sky130_fd_sc_hd__decap_3
XFILLER_51_319 VGND VGND VPWR VPWR sky130_fd_sc_hd__decap_3
XFILLER_91_477 VGND VGND VPWR VPWR sky130_fd_sc_hd__decap_3
XFILLER_17_596 VGND VGND VPWR VPWR sky130_fd_sc_hd__decap_3
XFILLER_32_533 VGND VGND VPWR VPWR sky130_fd_sc_hd__decap_3
XFILLER_71_190 VGND VGND VPWR VPWR sky130_fd_sc_hd__decap_3
X_3850_ _6810_/Q _3656_/Y _3850_/B1 _6820_/Q VGND VGND VPWR VPWR _3850_/X sky130_fd_sc_hd__a22o_2
XTAP_TAPCELL_ROW_63_1047 VGND VPWR sky130_fd_sc_hd__tapvpwrvgnd_1
XTAP_TAPCELL_ROW_27_591 VGND VPWR sky130_fd_sc_hd__tapvpwrvgnd_1
X_3781_ _6949_/Q _3656_/Y _3850_/B1 _6961_/Q _3780_/X VGND VGND VPWR VPWR _3781_/X
+ sky130_fd_sc_hd__a221o_2
XFILLER_118_616 VGND VGND VPWR VPWR sky130_fd_sc_hd__decap_3
XFILLER_8_261 VGND VGND VPWR VPWR sky130_fd_sc_hd__decap_3
X_4402_ _7082_/Q _4102_/B _4432_/B1 _4401_/X VGND VGND VPWR VPWR _4403_/A sky130_fd_sc_hd__o211a_2
XFILLER_99_511 VGND VGND VPWR VPWR sky130_fd_sc_hd__decap_3
XFILLER_113_321 VGND VGND VPWR VPWR sky130_fd_sc_hd__fill_1
X_7121_ _7313_/CLK _7121_/D _6401_/Y VGND VGND VPWR VPWR _7121_/Q sky130_fd_sc_hd__dfrtp_2
X_4333_ _7127_/Q _4333_/A2 _4332_/X VGND VGND VPWR VPWR _4336_/A sky130_fd_sc_hd__a21o_2
XFILLER_99_555 VGND VGND VPWR VPWR sky130_fd_sc_hd__decap_3
XFILLER_99_544 VGND VGND VPWR VPWR sky130_fd_sc_hd__fill_2
XFILLER_101_505 VGND VGND VPWR VPWR sky130_fd_sc_hd__decap_3
XFILLER_115_18 VGND VGND VPWR VPWR sky130_fd_sc_hd__decap_3
XFILLER_59_408 VGND VGND VPWR VPWR sky130_fd_sc_hd__decap_3
XFILLER_87_706 VGND VGND VPWR VPWR sky130_fd_sc_hd__decap_3
X_7052_ _7371_/CLK _7052_/D _6332_/Y VGND VGND VPWR VPWR _7052_/Q sky130_fd_sc_hd__dfrtp_2
X_4264_ _4264_/A _4264_/B VGND VGND VPWR VPWR _4376_/B sky130_fd_sc_hd__nor2_2
XTAP_TAPCELL_ROW_74_1187 VGND VPWR sky130_fd_sc_hd__tapvpwrvgnd_1
XFILLER_99_588 VGND VGND VPWR VPWR sky130_fd_sc_hd__decap_3
XFILLER_101_549 VGND VGND VPWR VPWR sky130_fd_sc_hd__decap_3
XFILLER_39_110 VGND VGND VPWR VPWR sky130_fd_sc_hd__fill_2
XFILLER_86_227 VGND VGND VPWR VPWR sky130_fd_sc_hd__decap_3
XFILLER_79_290 VGND VGND VPWR VPWR sky130_fd_sc_hd__decap_3
X_4195_ _7135_/Q _4351_/B1 _4267_/B1 _7167_/Q VGND VGND VPWR VPWR _4195_/X sky130_fd_sc_hd__a22o_2
XFILLER_55_603 VGND VGND VPWR VPWR sky130_fd_sc_hd__decap_3
XFILLER_82_400 VGND VGND VPWR VPWR sky130_fd_sc_hd__decap_3
XFILLER_27_327 VGND VGND VPWR VPWR sky130_fd_sc_hd__decap_3
XFILLER_27_349 VGND VGND VPWR VPWR sky130_fd_sc_hd__decap_3
XFILLER_39_198 VGND VGND VPWR VPWR sky130_fd_sc_hd__decap_3
XFILLER_54_135 VGND VGND VPWR VPWR sky130_fd_sc_hd__decap_3
XFILLER_55_647 VGND VGND VPWR VPWR sky130_fd_sc_hd__decap_3
XFILLER_94_293 VGND VGND VPWR VPWR sky130_fd_sc_hd__decap_3
XFILLER_70_628 VGND VGND VPWR VPWR sky130_fd_sc_hd__decap_3
XFILLER_82_477 VGND VGND VPWR VPWR sky130_fd_sc_hd__decap_3
X_6905_ _6942_/CLK _6905_/D VGND VGND VPWR VPWR _6905_/Q sky130_fd_sc_hd__dfxtp_2
XFILLER_23_511 VGND VGND VPWR VPWR sky130_fd_sc_hd__decap_3
XFILLER_23_533 VGND VGND VPWR VPWR sky130_fd_sc_hd__decap_3
XFILLER_63_691 VGND VGND VPWR VPWR sky130_fd_sc_hd__decap_3
XFILLER_11_706 VGND VGND VPWR VPWR sky130_fd_sc_hd__decap_3
XFILLER_35_393 VGND VGND VPWR VPWR sky130_fd_sc_hd__decap_3
X_6836_ _6906_/CLK _6836_/D VGND VGND VPWR VPWR _6836_/Q sky130_fd_sc_hd__dfxtp_2
XFILLER_23_577 VGND VGND VPWR VPWR sky130_fd_sc_hd__decap_3
XFILLER_23_588 VGND VGND VPWR VPWR sky130_fd_sc_hd__decap_3
X_6767_ clkload4/A _6767_/D VGND VGND VPWR VPWR _6767_/Q sky130_fd_sc_hd__dfxtp_2
XFILLER_109_605 VGND VGND VPWR VPWR sky130_fd_sc_hd__decap_3
X_3979_ _7351_/Q _4520_/A0 _3996_/S VGND VGND VPWR VPWR _7351_/D sky130_fd_sc_hd__mux2_2
XFILLER_109_638 VGND VGND VPWR VPWR sky130_fd_sc_hd__decap_3
X_6698_ _6922_/CLK _6698_/D VGND VGND VPWR VPWR _6698_/Q sky130_fd_sc_hd__dfxtp_2
XFILLER_108_159 VGND VGND VPWR VPWR sky130_fd_sc_hd__decap_3
X_5649_ _5649_/A VGND VGND VPWR VPWR _5649_/X sky130_fd_sc_hd__buf_1
XFILLER_117_671 VGND VGND VPWR VPWR sky130_fd_sc_hd__fill_1
XFILLER_104_321 VGND VGND VPWR VPWR sky130_fd_sc_hd__decap_3
XFILLER_117_682 VGND VGND VPWR VPWR sky130_fd_sc_hd__decap_3
X_7319_ _7322_/CLK _7319_/D _6599_/Y VGND VGND VPWR VPWR _7319_/Q sky130_fd_sc_hd__dfrtp_2
XFILLER_104_365 VGND VGND VPWR VPWR sky130_fd_sc_hd__decap_3
XFILLER_104_398 VGND VGND VPWR VPWR sky130_fd_sc_hd__decap_3
XFILLER_49_89 VGND VGND VPWR VPWR sky130_fd_sc_hd__decap_3
XFILLER_58_430 VGND VGND VPWR VPWR sky130_fd_sc_hd__decap_3
XFILLER_93_709 VGND VGND VPWR VPWR sky130_fd_sc_hd__decap_3
XFILLER_18_305 VGND VGND VPWR VPWR sky130_fd_sc_hd__decap_3
XFILLER_45_102 VGND VGND VPWR VPWR sky130_fd_sc_hd__fill_2
XFILLER_46_625 VGND VGND VPWR VPWR sky130_fd_sc_hd__decap_3
XFILLER_58_463 VGND VGND VPWR VPWR sky130_fd_sc_hd__decap_3
XFILLER_58_485 VGND VGND VPWR VPWR sky130_fd_sc_hd__decap_3
XFILLER_65_33 VGND VGND VPWR VPWR sky130_fd_sc_hd__fill_1
XFILLER_45_113 VGND VGND VPWR VPWR sky130_fd_sc_hd__fill_2
XFILLER_85_293 VGND VGND VPWR VPWR sky130_fd_sc_hd__decap_3
XFILLER_33_308 VGND VGND VPWR VPWR sky130_fd_sc_hd__decap_3
XFILLER_46_669 VGND VGND VPWR VPWR sky130_fd_sc_hd__decap_3
XFILLER_61_617 VGND VGND VPWR VPWR sky130_fd_sc_hd__decap_3
XFILLER_73_455 VGND VGND VPWR VPWR sky130_fd_sc_hd__decap_3
XTAP_TAPCELL_ROW_44_804 VGND VPWR sky130_fd_sc_hd__tapvpwrvgnd_1
XFILLER_26_360 VGND VGND VPWR VPWR sky130_fd_sc_hd__decap_3
XFILLER_60_105 VGND VGND VPWR VPWR sky130_fd_sc_hd__decap_3
XFILLER_73_488 VGND VGND VPWR VPWR sky130_fd_sc_hd__decap_3
XFILLER_14_533 VGND VGND VPWR VPWR sky130_fd_sc_hd__fill_2
XFILLER_14_544 VGND VGND VPWR VPWR sky130_fd_sc_hd__fill_2
XTAP_TAPCELL_ROW_24_561 VGND VPWR sky130_fd_sc_hd__tapvpwrvgnd_1
XFILLER_41_396 VGND VGND VPWR VPWR sky130_fd_sc_hd__decap_3
XFILLER_81_98 VGND VGND VPWR VPWR sky130_fd_sc_hd__decap_3
XFILLER_6_710 VGND VGND VPWR VPWR sky130_fd_sc_hd__decap_3
XFILLER_115_608 VGND VGND VPWR VPWR sky130_fd_sc_hd__decap_3
XFILLER_5_220 VGND VGND VPWR VPWR sky130_fd_sc_hd__decap_3
XFILLER_108_660 VGND VGND VPWR VPWR sky130_fd_sc_hd__decap_3
XFILLER_5_242 VGND VGND VPWR VPWR sky130_fd_sc_hd__decap_3
XFILLER_5_264 VGND VGND VPWR VPWR sky130_fd_sc_hd__decap_3
XFILLER_108_693 VGND VGND VPWR VPWR sky130_fd_sc_hd__decap_3
XFILLER_69_706 VGND VGND VPWR VPWR sky130_fd_sc_hd__decap_3
XFILLER_110_324 VGND VGND VPWR VPWR sky130_fd_sc_hd__decap_3
XFILLER_96_536 VGND VGND VPWR VPWR sky130_fd_sc_hd__decap_3
XFILLER_1_481 VGND VGND VPWR VPWR sky130_fd_sc_hd__decap_3
XFILLER_110_368 VGND VGND VPWR VPWR sky130_fd_sc_hd__decap_3
XFILLER_37_614 VGND VGND VPWR VPWR sky130_fd_sc_hd__fill_2
XFILLER_49_463 VGND VGND VPWR VPWR sky130_fd_sc_hd__fill_2
XFILLER_49_485 VGND VGND VPWR VPWR sky130_fd_sc_hd__decap_3
XFILLER_83_208 VGND VGND VPWR VPWR sky130_fd_sc_hd__decap_3
XFILLER_37_647 VGND VGND VPWR VPWR sky130_fd_sc_hd__decap_3
XFILLER_64_477 VGND VGND VPWR VPWR sky130_fd_sc_hd__decap_3
XFILLER_24_319 VGND VGND VPWR VPWR sky130_fd_sc_hd__fill_1
XFILLER_36_179 VGND VGND VPWR VPWR sky130_fd_sc_hd__decap_3
XFILLER_45_691 VGND VGND VPWR VPWR sky130_fd_sc_hd__decap_3
XFILLER_52_628 VGND VGND VPWR VPWR sky130_fd_sc_hd__decap_3
XFILLER_91_274 VGND VGND VPWR VPWR sky130_fd_sc_hd__decap_3
X_4951_ _4949_/Y _4950_/Y _4918_/B VGND VGND VPWR VPWR _4951_/Y sky130_fd_sc_hd__a21oi_2
XFILLER_17_393 VGND VGND VPWR VPWR sky130_fd_sc_hd__decap_3
XFILLER_51_149 VGND VGND VPWR VPWR sky130_fd_sc_hd__decap_3
X_4882_ _4882_/A _4882_/B VGND VGND VPWR VPWR _6998_/D sky130_fd_sc_hd__and2_2
X_3902_ _6918_/Q _3921_/A2 _3922_/B1 _6870_/Q VGND VGND VPWR VPWR _3902_/X sky130_fd_sc_hd__a22o_2
XFILLER_32_352 VGND VGND VPWR VPWR sky130_fd_sc_hd__decap_3
XFILLER_60_672 VGND VGND VPWR VPWR sky130_fd_sc_hd__decap_3
X_6621_ _6621_/A VGND VGND VPWR VPWR _6621_/Y sky130_fd_sc_hd__inv_2
X_3833_ _3833_/A0 _3832_/X _3864_/S VGND VGND VPWR VPWR _7388_/D sky130_fd_sc_hd__mux2_2
X_6552_ _6654_/A VGND VGND VPWR VPWR _6552_/Y sky130_fd_sc_hd__inv_2
X_3764_ _6706_/Q _6796_/Q _6884_/Q _6932_/Q _3991_/B _3661_/B VGND VGND VPWR VPWR
+ _3764_/X sky130_fd_sc_hd__mux4_2
XPHY_EDGE_ROW_89_Left_209 VGND VGND VPWR VPWR sky130_fd_sc_hd__decap_3
XFILLER_9_570 VGND VGND VPWR VPWR sky130_fd_sc_hd__decap_3
X_6483_ _6483_/A VGND VGND VPWR VPWR _6483_/Y sky130_fd_sc_hd__inv_2
X_3695_ _6714_/Q _3760_/B1 _3767_/B1 _6892_/Q VGND VGND VPWR VPWR _3695_/X sky130_fd_sc_hd__a22o_2
XTAP_TAPCELL_ROW_76_1205 VGND VPWR sky130_fd_sc_hd__tapvpwrvgnd_1
XFILLER_106_619 VGND VGND VPWR VPWR sky130_fd_sc_hd__decap_3
XFILLER_105_129 VGND VGND VPWR VPWR sky130_fd_sc_hd__decap_3
XFILLER_99_330 VGND VGND VPWR VPWR sky130_fd_sc_hd__decap_3
XFILLER_114_663 VGND VGND VPWR VPWR sky130_fd_sc_hd__decap_3
XFILLER_87_503 VGND VGND VPWR VPWR sky130_fd_sc_hd__fill_1
X_7104_ _7360_/CLK _7104_/D _6384_/Y VGND VGND VPWR VPWR _7104_/Q sky130_fd_sc_hd__dfrtp_2
X_5365_ _5365_/A0 _4716_/X _5379_/S VGND VGND VPWR VPWR _7150_/D sky130_fd_sc_hd__mux2_4
XFILLER_101_313 VGND VGND VPWR VPWR sky130_fd_sc_hd__decap_3
XFILLER_114_696 VGND VGND VPWR VPWR sky130_fd_sc_hd__decap_3
XFILLER_59_205 VGND VGND VPWR VPWR sky130_fd_sc_hd__decap_3
X_5296_ _5296_/A0 _4716_/X _5315_/S VGND VGND VPWR VPWR _7182_/D sky130_fd_sc_hd__mux2_4
X_4316_ _7226_/Q _4349_/B1 _4348_/B1 _7130_/Q VGND VGND VPWR VPWR _4316_/X sky130_fd_sc_hd__a22o_2
XFILLER_101_346 VGND VGND VPWR VPWR sky130_fd_sc_hd__decap_3
XFILLER_75_709 VGND VGND VPWR VPWR sky130_fd_sc_hd__decap_3
X_7035_ _7349_/CLK _7035_/D _6315_/Y VGND VGND VPWR VPWR _7035_/Q sky130_fd_sc_hd__dfrtp_2
X_4247_ _7261_/Q _4356_/A2 _3964_/S _7325_/Q _4246_/X VGND VGND VPWR VPWR _4248_/C
+ sky130_fd_sc_hd__a221o_2
XFILLER_28_625 VGND VGND VPWR VPWR sky130_fd_sc_hd__decap_3
XFILLER_74_219 VGND VGND VPWR VPWR sky130_fd_sc_hd__decap_3
X_4178_ _7264_/Q _4356_/A2 _4177_/X VGND VGND VPWR VPWR _4178_/Y sky130_fd_sc_hd__a21oi_2
XPHY_EDGE_ROW_98_Left_218 VGND VGND VPWR VPWR sky130_fd_sc_hd__decap_3
XFILLER_27_113 VGND VGND VPWR VPWR sky130_fd_sc_hd__decap_3
XFILLER_55_444 VGND VGND VPWR VPWR sky130_fd_sc_hd__decap_3
XFILLER_67_271 VGND VGND VPWR VPWR sky130_fd_sc_hd__decap_3
XFILLER_95_591 VGND VGND VPWR VPWR sky130_fd_sc_hd__decap_3
XFILLER_15_308 VGND VGND VPWR VPWR sky130_fd_sc_hd__decap_3
XFILLER_28_669 VGND VGND VPWR VPWR sky130_fd_sc_hd__decap_3
XFILLER_43_606 VGND VGND VPWR VPWR sky130_fd_sc_hd__decap_3
XFILLER_43_617 VGND VGND VPWR VPWR sky130_fd_sc_hd__decap_3
XTAP_TAPCELL_ROW_87_1345 VGND VPWR sky130_fd_sc_hd__tapvpwrvgnd_1
XTAP_TAPCELL_ROW_2_289 VGND VPWR sky130_fd_sc_hd__tapvpwrvgnd_1
XTAP_TAPCELL_ROW_2_278 VGND VPWR sky130_fd_sc_hd__tapvpwrvgnd_1
XFILLER_55_499 VGND VGND VPWR VPWR sky130_fd_sc_hd__decap_3
XFILLER_35_190 VGND VGND VPWR VPWR sky130_fd_sc_hd__decap_3
XFILLER_51_650 VGND VGND VPWR VPWR sky130_fd_sc_hd__decap_3
X_6819_ _6968_/CLK _6819_/D VGND VGND VPWR VPWR _6819_/Q sky130_fd_sc_hd__dfxtp_2
XFILLER_11_547 VGND VGND VPWR VPWR sky130_fd_sc_hd__decap_3
XFILLER_50_182 VGND VGND VPWR VPWR sky130_fd_sc_hd__decap_3
XFILLER_51_694 VGND VGND VPWR VPWR sky130_fd_sc_hd__decap_3
XTAP_TAPCELL_ROW_21_520 VGND VPWR sky130_fd_sc_hd__tapvpwrvgnd_1
XFILLER_109_402 VGND VGND VPWR VPWR sky130_fd_sc_hd__decap_3
XFILLER_51_57 VGND VGND VPWR VPWR sky130_fd_sc_hd__decap_3
XFILLER_51_79 VGND VGND VPWR VPWR sky130_fd_sc_hd__decap_3
XTAP_TAPCELL_ROW_98_1485 VGND VPWR sky130_fd_sc_hd__tapvpwrvgnd_1
XFILLER_105_641 VGND VGND VPWR VPWR sky130_fd_sc_hd__decap_3
XFILLER_2_256 VGND VGND VPWR VPWR sky130_fd_sc_hd__decap_3
XFILLER_104_162 VGND VGND VPWR VPWR sky130_fd_sc_hd__decap_3
XFILLER_105_685 VGND VGND VPWR VPWR sky130_fd_sc_hd__decap_3
XFILLER_116_50 VGND VGND VPWR VPWR sky130_fd_sc_hd__decap_3
XFILLER_2_267 VGND VGND VPWR VPWR sky130_fd_sc_hd__fill_2
XFILLER_78_514 VGND VGND VPWR VPWR sky130_fd_sc_hd__decap_3
XFILLER_78_536 VGND VGND VPWR VPWR sky130_fd_sc_hd__decap_3
XFILLER_104_195 VGND VGND VPWR VPWR sky130_fd_sc_hd__fill_1
XFILLER_116_83 VGND VGND VPWR VPWR sky130_fd_sc_hd__fill_1
XFILLER_116_94 VGND VGND VPWR VPWR sky130_fd_sc_hd__decap_3
XFILLER_76_32 VGND VGND VPWR VPWR sky130_fd_sc_hd__decap_3
XFILLER_19_647 VGND VGND VPWR VPWR sky130_fd_sc_hd__decap_3
XFILLER_86_580 VGND VGND VPWR VPWR sky130_fd_sc_hd__decap_3
XTAP_TAPCELL_ROW_29_620 VGND VPWR sky130_fd_sc_hd__tapvpwrvgnd_1
XFILLER_100_390 VGND VGND VPWR VPWR sky130_fd_sc_hd__decap_3
XFILLER_46_444 VGND VGND VPWR VPWR sky130_fd_sc_hd__decap_3
XFILLER_46_477 VGND VGND VPWR VPWR sky130_fd_sc_hd__decap_3
XTAP_TAPCELL_ROW_57_973 VGND VPWR sky130_fd_sc_hd__tapvpwrvgnd_1
XFILLER_18_179 VGND VGND VPWR VPWR sky130_fd_sc_hd__decap_3
XFILLER_33_116 VGND VGND VPWR VPWR sky130_fd_sc_hd__decap_3
XFILLER_34_628 VGND VGND VPWR VPWR sky130_fd_sc_hd__decap_3
XFILLER_26_190 VGND VGND VPWR VPWR sky130_fd_sc_hd__decap_3
XFILLER_27_691 VGND VGND VPWR VPWR sky130_fd_sc_hd__decap_3
XFILLER_61_469 VGND VGND VPWR VPWR sky130_fd_sc_hd__fill_2
XFILLER_92_75 VGND VGND VPWR VPWR sky130_fd_sc_hd__decap_3
XFILLER_92_97 VGND VGND VPWR VPWR sky130_fd_sc_hd__decap_3
XTAP_TAPCELL_ROW_107_1592 VGND VPWR sky130_fd_sc_hd__tapvpwrvgnd_1
XFILLER_14_352 VGND VGND VPWR VPWR sky130_fd_sc_hd__decap_3
XFILLER_42_672 VGND VGND VPWR VPWR sky130_fd_sc_hd__decap_3
XTAP_TAPCELL_ROW_60_1006 VGND VPWR sky130_fd_sc_hd__tapvpwrvgnd_1
XFILLER_41_160 VGND VGND VPWR VPWR sky130_fd_sc_hd__decap_3
XFILLER_41_90 VGND VGND VPWR VPWR sky130_fd_sc_hd__decap_3
XFILLER_6_551 VGND VGND VPWR VPWR sky130_fd_sc_hd__decap_3
X_3480_ _7088_/Q _3417_/X _4333_/A2 _7120_/Q VGND VGND VPWR VPWR _3482_/B sky130_fd_sc_hd__a22o_2
XFILLER_6_584 VGND VGND VPWR VPWR sky130_fd_sc_hd__decap_3
XFILLER_6_595 VGND VGND VPWR VPWR sky130_fd_sc_hd__decap_3
XFILLER_111_600 VGND VGND VPWR VPWR sky130_fd_sc_hd__decap_3
XFILLER_37_3 VGND VGND VPWR VPWR sky130_fd_sc_hd__fill_1
X_5150_ _3501_/X _3618_/X _5145_/X _5149_/Y VGND VGND VPWR VPWR _5659_/B sky130_fd_sc_hd__a31o_2
XFILLER_110_121 VGND VGND VPWR VPWR sky130_fd_sc_hd__decap_3
XFILLER_111_644 VGND VGND VPWR VPWR sky130_fd_sc_hd__decap_3
XFILLER_57_709 VGND VGND VPWR VPWR sky130_fd_sc_hd__decap_3
XFILLER_69_558 VGND VGND VPWR VPWR sky130_fd_sc_hd__fill_2
XFILLER_96_322 VGND VGND VPWR VPWR sky130_fd_sc_hd__fill_2
XFILLER_96_355 VGND VGND VPWR VPWR sky130_fd_sc_hd__fill_1
X_4101_ _7141_/Q _4263_/A2 _4100_/X VGND VGND VPWR VPWR _4141_/A sky130_fd_sc_hd__a21oi_2
XTAP_TAPCELL_ROW_71_1146 VGND VPWR sky130_fd_sc_hd__tapvpwrvgnd_1
XFILLER_110_154 VGND VGND VPWR VPWR sky130_fd_sc_hd__decap_3
XFILLER_111_688 VGND VGND VPWR VPWR sky130_fd_sc_hd__decap_3
XFILLER_49_260 VGND VGND VPWR VPWR sky130_fd_sc_hd__decap_3
XFILLER_96_377 VGND VGND VPWR VPWR sky130_fd_sc_hd__decap_3
X_4032_ _7246_/Q _4433_/B _3954_/S _7214_/Q VGND VGND VPWR VPWR _4032_/X sky130_fd_sc_hd__a22o_2
XFILLER_49_293 VGND VGND VPWR VPWR sky130_fd_sc_hd__decap_3
XFILLER_37_444 VGND VGND VPWR VPWR sky130_fd_sc_hd__decap_3
XFILLER_37_466 VGND VGND VPWR VPWR sky130_fd_sc_hd__decap_3
XFILLER_80_701 VGND VGND VPWR VPWR sky130_fd_sc_hd__decap_3
XFILLER_25_617 VGND VGND VPWR VPWR sky130_fd_sc_hd__decap_3
XFILLER_64_274 VGND VGND VPWR VPWR sky130_fd_sc_hd__decap_3
XFILLER_24_138 VGND VGND VPWR VPWR sky130_fd_sc_hd__fill_2
XFILLER_52_436 VGND VGND VPWR VPWR sky130_fd_sc_hd__decap_3
XFILLER_33_650 VGND VGND VPWR VPWR sky130_fd_sc_hd__decap_3
XFILLER_20_300 VGND VGND VPWR VPWR sky130_fd_sc_hd__decap_3
XFILLER_20_333 VGND VGND VPWR VPWR sky130_fd_sc_hd__fill_2
XFILLER_32_160 VGND VGND VPWR VPWR sky130_fd_sc_hd__decap_3
XFILLER_33_694 VGND VGND VPWR VPWR sky130_fd_sc_hd__decap_3
X_4865_ _7270_/Q _4864_/X _4865_/S VGND VGND VPWR VPWR _7270_/D sky130_fd_sc_hd__mux2_2
XTAP_TAPCELL_ROW_82_1286 VGND VPWR sky130_fd_sc_hd__tapvpwrvgnd_1
X_6604_ _6640_/A VGND VGND VPWR VPWR _6604_/Y sky130_fd_sc_hd__inv_2
X_4796_ _4795_/A _4779_/X _4447_/B _4780_/Y _4814_/A VGND VGND VPWR VPWR _4796_/Y
+ sky130_fd_sc_hd__a311oi_2
X_3816_ _6792_/Q _3926_/B1 _3925_/B1 _6880_/Q _3815_/X VGND VGND VPWR VPWR _3816_/X
+ sky130_fd_sc_hd__a221o_2
X_6535_ _6535_/A VGND VGND VPWR VPWR _6535_/Y sky130_fd_sc_hd__inv_2
X_3747_ _3741_/X _3743_/X _3745_/X _3746_/X VGND VGND VPWR VPWR _3747_/X sky130_fd_sc_hd__a22o_2
XFILLER_118_265 VGND VGND VPWR VPWR sky130_fd_sc_hd__fill_1
XFILLER_21_49 VGND VGND VPWR VPWR sky130_fd_sc_hd__decap_3
XFILLER_106_416 VGND VGND VPWR VPWR sky130_fd_sc_hd__decap_3
XFILLER_106_427 VGND VGND VPWR VPWR sky130_fd_sc_hd__decap_3
XFILLER_108_9 VGND VGND VPWR VPWR sky130_fd_sc_hd__decap_3
X_6466_ _6624_/A VGND VGND VPWR VPWR _6466_/Y sky130_fd_sc_hd__inv_2
X_6397_ _6653_/A VGND VGND VPWR VPWR _6397_/Y sky130_fd_sc_hd__inv_2
X_5417_ _5417_/A0 _5125_/Y _5429_/S VGND VGND VPWR VPWR _7125_/D sky130_fd_sc_hd__mux2_2
XFILLER_102_622 VGND VGND VPWR VPWR sky130_fd_sc_hd__decap_3
X_5348_ _7157_/Q _5125_/Y _5360_/S VGND VGND VPWR VPWR _7157_/D sky130_fd_sc_hd__mux2_2
XTAP_TAPCELL_ROW_7_348 VGND VPWR sky130_fd_sc_hd__tapvpwrvgnd_1
XFILLER_99_160 VGND VGND VPWR VPWR sky130_fd_sc_hd__decap_3
XFILLER_101_143 VGND VGND VPWR VPWR sky130_fd_sc_hd__decap_3
XFILLER_102_666 VGND VGND VPWR VPWR sky130_fd_sc_hd__decap_3
XFILLER_47_208 VGND VGND VPWR VPWR sky130_fd_sc_hd__decap_3
XFILLER_75_528 VGND VGND VPWR VPWR sky130_fd_sc_hd__decap_3
XFILLER_87_355 VGND VGND VPWR VPWR sky130_fd_sc_hd__decap_3
X_7018_ _7333_/CLK _7018_/D _6298_/Y VGND VGND VPWR VPWR _7018_/Q sky130_fd_sc_hd__dfrtp_2
XFILLER_101_187 VGND VGND VPWR VPWR sky130_fd_sc_hd__decap_3
XFILLER_102_699 VGND VGND VPWR VPWR sky130_fd_sc_hd__fill_1
XFILLER_28_433 VGND VGND VPWR VPWR sky130_fd_sc_hd__decap_3
XFILLER_68_580 VGND VGND VPWR VPWR sky130_fd_sc_hd__fill_2
XFILLER_55_252 VGND VGND VPWR VPWR sky130_fd_sc_hd__decap_3
XFILLER_83_550 VGND VGND VPWR VPWR sky130_fd_sc_hd__fill_2
XFILLER_15_105 VGND VGND VPWR VPWR sky130_fd_sc_hd__decap_3
XFILLER_16_628 VGND VGND VPWR VPWR sky130_fd_sc_hd__decap_3
XFILLER_28_477 VGND VGND VPWR VPWR sky130_fd_sc_hd__decap_3
XFILLER_43_425 VGND VGND VPWR VPWR sky130_fd_sc_hd__decap_3
XFILLER_70_200 VGND VGND VPWR VPWR sky130_fd_sc_hd__decap_3
XFILLER_71_712 VGND VGND VPWR VPWR sky130_fd_sc_hd__fill_2
XFILLER_83_594 VGND VGND VPWR VPWR sky130_fd_sc_hd__decap_3
XFILLER_43_458 VGND VGND VPWR VPWR sky130_fd_sc_hd__decap_3
XTAP_TAPCELL_ROW_54_932 VGND VPWR sky130_fd_sc_hd__tapvpwrvgnd_1
XFILLER_102_74 VGND VGND VPWR VPWR sky130_fd_sc_hd__decap_3
XFILLER_102_85 VGND VGND VPWR VPWR sky130_fd_sc_hd__decap_3
XFILLER_24_672 VGND VGND VPWR VPWR sky130_fd_sc_hd__decap_3
XFILLER_62_23 VGND VGND VPWR VPWR sky130_fd_sc_hd__decap_3
XFILLER_70_277 VGND VGND VPWR VPWR sky130_fd_sc_hd__decap_3
XFILLER_70_299 VGND VGND VPWR VPWR sky130_fd_sc_hd__decap_3
XFILLER_11_399 VGND VGND VPWR VPWR sky130_fd_sc_hd__decap_3
XFILLER_7_337 VGND VGND VPWR VPWR sky130_fd_sc_hd__decap_3
XFILLER_109_243 VGND VGND VPWR VPWR sky130_fd_sc_hd__decap_3
XFILLER_109_287 VGND VGND VPWR VPWR sky130_fd_sc_hd__decap_3
XFILLER_11_93 VGND VGND VPWR VPWR sky130_fd_sc_hd__decap_3
XFILLER_3_532 VGND VGND VPWR VPWR sky130_fd_sc_hd__decap_3
XFILLER_3_576 VGND VGND VPWR VPWR sky130_fd_sc_hd__decap_3
XFILLER_87_31 VGND VGND VPWR VPWR sky130_fd_sc_hd__decap_3
XFILLER_39_709 VGND VGND VPWR VPWR sky130_fd_sc_hd__decap_3
XFILLER_66_517 VGND VGND VPWR VPWR sky130_fd_sc_hd__decap_3
XFILLER_87_97 VGND VGND VPWR VPWR sky130_fd_sc_hd__decap_3
XFILLER_19_433 VGND VGND VPWR VPWR sky130_fd_sc_hd__decap_3
XFILLER_78_399 VGND VGND VPWR VPWR sky130_fd_sc_hd__decap_3
XFILLER_93_314 VGND VGND VPWR VPWR sky130_fd_sc_hd__decap_3
XTAP_TAPCELL_ROW_109_1621 VGND VPWR sky130_fd_sc_hd__tapvpwrvgnd_1
XFILLER_19_455 VGND VGND VPWR VPWR sky130_fd_sc_hd__decap_3
XFILLER_62_701 VGND VGND VPWR VPWR sky130_fd_sc_hd__decap_3
XFILLER_19_488 VGND VGND VPWR VPWR sky130_fd_sc_hd__decap_3
XFILLER_34_414 VGND VGND VPWR VPWR sky130_fd_sc_hd__decap_3
XFILLER_46_274 VGND VGND VPWR VPWR sky130_fd_sc_hd__decap_3
XFILLER_74_561 VGND VGND VPWR VPWR sky130_fd_sc_hd__decap_3
XFILLER_74_583 VGND VGND VPWR VPWR sky130_fd_sc_hd__decap_3
XFILLER_61_222 VGND VGND VPWR VPWR sky130_fd_sc_hd__fill_2
XFILLER_61_233 VGND VGND VPWR VPWR sky130_fd_sc_hd__decap_3
XFILLER_15_650 VGND VGND VPWR VPWR sky130_fd_sc_hd__decap_3
XFILLER_15_694 VGND VGND VPWR VPWR sky130_fd_sc_hd__decap_3
XFILLER_21_119 VGND VGND VPWR VPWR sky130_fd_sc_hd__decap_3
XFILLER_30_631 VGND VGND VPWR VPWR sky130_fd_sc_hd__decap_3
XFILLER_42_480 VGND VGND VPWR VPWR sky130_fd_sc_hd__fill_1
X_4650_ _4440_/A _4650_/B VGND VGND VPWR VPWR _4810_/B sky130_fd_sc_hd__and2b_2
XTAP_TAPCELL_ROW_32_659 VGND VPWR sky130_fd_sc_hd__tapvpwrvgnd_1
XFILLER_30_675 VGND VGND VPWR VPWR sky130_fd_sc_hd__decap_3
X_3601_ _3427_/B _3600_/Y _3599_/A VGND VGND VPWR VPWR _4613_/B sky130_fd_sc_hd__a21oi_2
X_6320_ _6667_/A VGND VGND VPWR VPWR _6320_/Y sky130_fd_sc_hd__inv_2
X_4581_ _4581_/A _4593_/B VGND VGND VPWR VPWR _7290_/D sky130_fd_sc_hd__and2_2
Xhold805 _6836_/Q VGND VGND VPWR VPWR _6836_/D sky130_fd_sc_hd__dlygate4sd3_1
Xhold816 _6722_/Q VGND VGND VPWR VPWR _6722_/D sky130_fd_sc_hd__dlygate4sd3_1
Xhold827 _6876_/Q VGND VGND VPWR VPWR _6876_/D sky130_fd_sc_hd__dlygate4sd3_1
X_3532_ _3324_/A _3509_/Y _5642_/B _5659_/A _3566_/A2 VGND VGND VPWR VPWR _3621_/A
+ sky130_fd_sc_hd__a41o_2
Xhold838 _6788_/Q VGND VGND VPWR VPWR _6788_/D sky130_fd_sc_hd__dlygate4sd3_1
Xhold849 _6775_/Q VGND VGND VPWR VPWR _6775_/D sky130_fd_sc_hd__dlygate4sd3_1
X_3463_ _7057_/Q _4305_/B _3590_/A _3462_/X VGND VGND VPWR VPWR _3545_/A sky130_fd_sc_hd__o211ai_4
XFILLER_69_311 VGND VGND VPWR VPWR sky130_fd_sc_hd__decap_3
XFILLER_97_620 VGND VGND VPWR VPWR sky130_fd_sc_hd__decap_3
XFILLER_69_333 VGND VGND VPWR VPWR sky130_fd_sc_hd__decap_3
XFILLER_97_653 VGND VGND VPWR VPWR sky130_fd_sc_hd__decap_3
X_3394_ _3394_/A _3429_/B VGND VGND VPWR VPWR _3558_/B sky130_fd_sc_hd__or2_2
XFILLER_111_441 VGND VGND VPWR VPWR sky130_fd_sc_hd__decap_3
XFILLER_29_208 VGND VGND VPWR VPWR sky130_fd_sc_hd__decap_3
XFILLER_57_517 VGND VGND VPWR VPWR sky130_fd_sc_hd__fill_1
XFILLER_69_355 VGND VGND VPWR VPWR sky130_fd_sc_hd__decap_3
XFILLER_96_141 VGND VGND VPWR VPWR sky130_fd_sc_hd__decap_3
XTAP_TAPCELL_ROW_4_307 VGND VPWR sky130_fd_sc_hd__tapvpwrvgnd_1
XFILLER_57_539 VGND VGND VPWR VPWR sky130_fd_sc_hd__decap_3
XFILLER_96_174 VGND VGND VPWR VPWR sky130_fd_sc_hd__decap_3
XFILLER_97_697 VGND VGND VPWR VPWR sky130_fd_sc_hd__decap_3
XFILLER_84_347 VGND VGND VPWR VPWR sky130_fd_sc_hd__decap_3
XFILLER_37_263 VGND VGND VPWR VPWR sky130_fd_sc_hd__decap_3
XFILLER_53_712 VGND VGND VPWR VPWR sky130_fd_sc_hd__fill_2
XFILLER_65_561 VGND VGND VPWR VPWR sky130_fd_sc_hd__fill_1
XTAP_TAPCELL_ROW_84_1304 VGND VPWR sky130_fd_sc_hd__tapvpwrvgnd_1
XFILLER_16_27 VGND VGND VPWR VPWR sky130_fd_sc_hd__fill_1
XFILLER_16_49 VGND VGND VPWR VPWR sky130_fd_sc_hd__decap_3
XFILLER_25_436 VGND VGND VPWR VPWR sky130_fd_sc_hd__decap_3
XFILLER_52_233 VGND VGND VPWR VPWR sky130_fd_sc_hd__decap_3
XFILLER_92_391 VGND VGND VPWR VPWR sky130_fd_sc_hd__decap_3
XFILLER_13_609 VGND VGND VPWR VPWR sky130_fd_sc_hd__decap_3
XFILLER_80_586 VGND VGND VPWR VPWR sky130_fd_sc_hd__fill_2
XFILLER_21_620 VGND VGND VPWR VPWR sky130_fd_sc_hd__decap_3
XFILLER_40_439 VGND VGND VPWR VPWR sky130_fd_sc_hd__fill_1
XFILLER_52_288 VGND VGND VPWR VPWR sky130_fd_sc_hd__decap_3
X_4917_ _4967_/A _4950_/A _4967_/B VGND VGND VPWR VPWR _4918_/B sky130_fd_sc_hd__and3_2
XFILLER_20_141 VGND VGND VPWR VPWR sky130_fd_sc_hd__decap_3
XFILLER_21_653 VGND VGND VPWR VPWR sky130_fd_sc_hd__decap_3
X_4848_ _4884_/A _4904_/B _4140_/X VGND VGND VPWR VPWR _4872_/B sky130_fd_sc_hd__o21ba_2
XFILLER_21_697 VGND VGND VPWR VPWR sky130_fd_sc_hd__decap_3
XFILLER_107_703 VGND VGND VPWR VPWR sky130_fd_sc_hd__decap_3
X_4779_ _4779_/A _4827_/B VGND VGND VPWR VPWR _4779_/X sky130_fd_sc_hd__or2_2
XFILLER_119_585 VGND VGND VPWR VPWR sky130_fd_sc_hd__decap_3
XFILLER_4_318 VGND VGND VPWR VPWR sky130_fd_sc_hd__decap_3
XFILLER_4_329 VGND VGND VPWR VPWR sky130_fd_sc_hd__fill_1
X_6518_ _6648_/A VGND VGND VPWR VPWR _6518_/Y sky130_fd_sc_hd__inv_2
XTAP_TAPCELL_ROW_95_1444 VGND VPWR sky130_fd_sc_hd__tapvpwrvgnd_1
X_6449_ _6645_/A VGND VGND VPWR VPWR _6449_/Y sky130_fd_sc_hd__inv_2
XFILLER_106_268 VGND VGND VPWR VPWR sky130_fd_sc_hd__decap_3
XFILLER_79_119 VGND VGND VPWR VPWR sky130_fd_sc_hd__decap_3
XFILLER_0_546 VGND VGND VPWR VPWR sky130_fd_sc_hd__decap_3
XFILLER_88_642 VGND VGND VPWR VPWR sky130_fd_sc_hd__fill_2
XFILLER_0_579 VGND VGND VPWR VPWR sky130_fd_sc_hd__decap_3
XFILLER_57_23 VGND VGND VPWR VPWR sky130_fd_sc_hd__fill_1
XFILLER_88_675 VGND VGND VPWR VPWR sky130_fd_sc_hd__decap_3
XFILLER_48_539 VGND VGND VPWR VPWR sky130_fd_sc_hd__decap_3
XFILLER_87_196 VGND VGND VPWR VPWR sky130_fd_sc_hd__decap_3
XFILLER_28_241 VGND VGND VPWR VPWR sky130_fd_sc_hd__decap_3
XFILLER_57_89 VGND VGND VPWR VPWR sky130_fd_sc_hd__fill_2
XFILLER_16_414 VGND VGND VPWR VPWR sky130_fd_sc_hd__decap_3
XFILLER_28_274 VGND VGND VPWR VPWR sky130_fd_sc_hd__decap_3
XFILLER_44_701 VGND VGND VPWR VPWR sky130_fd_sc_hd__decap_3
XFILLER_73_11 VGND VGND VPWR VPWR sky130_fd_sc_hd__fill_1
XFILLER_90_339 VGND VGND VPWR VPWR sky130_fd_sc_hd__fill_1
Xplace509 _6981_/Q VGND VGND VPWR VPWR _3371_/A sky130_fd_sc_hd__buf_2
XFILLER_113_84 VGND VGND VPWR VPWR sky130_fd_sc_hd__decap_3
XFILLER_28_285 VGND VGND VPWR VPWR sky130_fd_sc_hd__decap_3
XFILLER_43_211 VGND VGND VPWR VPWR sky130_fd_sc_hd__decap_3
XFILLER_83_391 VGND VGND VPWR VPWR sky130_fd_sc_hd__fill_1
XFILLER_73_77 VGND VGND VPWR VPWR sky130_fd_sc_hd__fill_1
XFILLER_12_631 VGND VGND VPWR VPWR sky130_fd_sc_hd__decap_3
XFILLER_24_480 VGND VGND VPWR VPWR sky130_fd_sc_hd__decap_3
XFILLER_43_299 VGND VGND VPWR VPWR sky130_fd_sc_hd__decap_3
XTAP_TAPCELL_ROW_104_1562 VGND VPWR sky130_fd_sc_hd__tapvpwrvgnd_1
XFILLER_8_613 VGND VGND VPWR VPWR sky130_fd_sc_hd__decap_3
XFILLER_12_675 VGND VGND VPWR VPWR sky130_fd_sc_hd__decap_3
XFILLER_7_101 VGND VGND VPWR VPWR sky130_fd_sc_hd__fill_2
XFILLER_11_196 VGND VGND VPWR VPWR sky130_fd_sc_hd__decap_3
XFILLER_7_156 VGND VGND VPWR VPWR sky130_fd_sc_hd__decap_3
XFILLER_8_657 VGND VGND VPWR VPWR sky130_fd_sc_hd__decap_3
XFILLER_113_706 VGND VGND VPWR VPWR sky130_fd_sc_hd__decap_3
XFILLER_3_340 VGND VGND VPWR VPWR sky130_fd_sc_hd__decap_3
XFILLER_98_406 VGND VGND VPWR VPWR sky130_fd_sc_hd__decap_3
XFILLER_98_85 VGND VGND VPWR VPWR sky130_fd_sc_hd__fill_1
XFILLER_98_74 VGND VGND VPWR VPWR sky130_fd_sc_hd__decap_3
XFILLER_79_620 VGND VGND VPWR VPWR sky130_fd_sc_hd__decap_3
XTAP_TAPCELL_ROW_115_1691 VGND VPWR sky130_fd_sc_hd__tapvpwrvgnd_1
XFILLER_98_96 VGND VGND VPWR VPWR sky130_fd_sc_hd__decap_3
XFILLER_39_517 VGND VGND VPWR VPWR sky130_fd_sc_hd__decap_3
XFILLER_66_303 VGND VGND VPWR VPWR sky130_fd_sc_hd__decap_3
XFILLER_78_130 VGND VGND VPWR VPWR sky130_fd_sc_hd__decap_3
XFILLER_78_141 VGND VGND VPWR VPWR sky130_fd_sc_hd__decap_3
XFILLER_79_653 VGND VGND VPWR VPWR sky130_fd_sc_hd__decap_3
XFILLER_78_163 VGND VGND VPWR VPWR sky130_fd_sc_hd__decap_3
XFILLER_79_697 VGND VGND VPWR VPWR sky130_fd_sc_hd__decap_3
XFILLER_93_111 VGND VGND VPWR VPWR sky130_fd_sc_hd__fill_1
XFILLER_93_122 VGND VGND VPWR VPWR sky130_fd_sc_hd__decap_3
XFILLER_94_634 VGND VGND VPWR VPWR sky130_fd_sc_hd__decap_3
XFILLER_94_645 VGND VGND VPWR VPWR sky130_fd_sc_hd__decap_3
XFILLER_94_678 VGND VGND VPWR VPWR sky130_fd_sc_hd__decap_3
XFILLER_19_274 VGND VGND VPWR VPWR sky130_fd_sc_hd__decap_3
XFILLER_34_200 VGND VGND VPWR VPWR sky130_fd_sc_hd__decap_3
XFILLER_35_712 VGND VGND VPWR VPWR sky130_fd_sc_hd__fill_2
XFILLER_47_561 VGND VGND VPWR VPWR sky130_fd_sc_hd__decap_3
XTAP_TAPCELL_ROW_37_718 VGND VPWR sky130_fd_sc_hd__tapvpwrvgnd_1
XFILLER_19_296 VGND VGND VPWR VPWR sky130_fd_sc_hd__fill_1
XFILLER_34_211 VGND VGND VPWR VPWR sky130_fd_sc_hd__decap_3
XFILLER_74_380 VGND VGND VPWR VPWR sky130_fd_sc_hd__decap_3
XFILLER_93_199 VGND VGND VPWR VPWR sky130_fd_sc_hd__decap_3
XFILLER_22_417 VGND VGND VPWR VPWR sky130_fd_sc_hd__decap_3
XFILLER_34_244 VGND VGND VPWR VPWR sky130_fd_sc_hd__decap_3
XFILLER_50_704 VGND VGND VPWR VPWR sky130_fd_sc_hd__decap_3
XTAP_TAPCELL_ROW_66_1078 VGND VPWR sky130_fd_sc_hd__tapvpwrvgnd_1
XFILLER_22_439 VGND VGND VPWR VPWR sky130_fd_sc_hd__decap_3
XTAP_TAPCELL_ROW_66_1089 VGND VPWR sky130_fd_sc_hd__tapvpwrvgnd_1
XTAP_TAPCELL_ROW_17_475 VGND VPWR sky130_fd_sc_hd__tapvpwrvgnd_1
X_4702_ _6991_/Q _5026_/A VGND VGND VPWR VPWR _5001_/A sky130_fd_sc_hd__and2_2
XFILLER_30_483 VGND VGND VPWR VPWR sky130_fd_sc_hd__decap_3
X_5682_ _5682_/A0 _6691_/Q _5708_/S VGND VGND VPWR VPWR _6691_/D sky130_fd_sc_hd__mux2_2
X_4633_ _4633_/A _4903_/A _4845_/A _4890_/B VGND VGND VPWR VPWR _4633_/X sky130_fd_sc_hd__or4_2
XFILLER_118_29 VGND VGND VPWR VPWR sky130_fd_sc_hd__decap_3
X_7352_ _7354_/CLK _7352_/D _6632_/Y VGND VGND VPWR VPWR _7352_/Q sky130_fd_sc_hd__dfrtp_2
XFILLER_116_533 VGND VGND VPWR VPWR sky130_fd_sc_hd__decap_3
XFILLER_116_544 VGND VGND VPWR VPWR sky130_fd_sc_hd__decap_3
X_7283_ _7350_/CLK _7283_/D _6563_/Y VGND VGND VPWR VPWR _7283_/Q sky130_fd_sc_hd__dfrtp_2
X_6303_ _6584_/A VGND VGND VPWR VPWR _6303_/Y sky130_fd_sc_hd__inv_2
X_3515_ _3509_/Y _3510_/X _3380_/Y VGND VGND VPWR VPWR _4938_/A sky130_fd_sc_hd__a21o_2
XFILLER_89_406 VGND VGND VPWR VPWR sky130_fd_sc_hd__decap_3
X_4495_ _4495_/A0 _4561_/A _4517_/S VGND VGND VPWR VPWR _7332_/D sky130_fd_sc_hd__mux2_2
XFILLER_103_249 VGND VGND VPWR VPWR sky130_fd_sc_hd__decap_3
XFILLER_89_439 VGND VGND VPWR VPWR sky130_fd_sc_hd__decap_3
XFILLER_69_152 VGND VGND VPWR VPWR sky130_fd_sc_hd__decap_3
X_3377_ _3394_/A _3429_/A _5641_/A _5161_/A VGND VGND VPWR VPWR _3377_/X sky130_fd_sc_hd__and4bb_4
XTAP_TAPCELL_ROW_90_1385 VGND VPWR sky130_fd_sc_hd__tapvpwrvgnd_1
XFILLER_111_271 VGND VGND VPWR VPWR sky130_fd_sc_hd__decap_3
XFILLER_57_314 VGND VGND VPWR VPWR sky130_fd_sc_hd__fill_2
XFILLER_84_100 VGND VGND VPWR VPWR sky130_fd_sc_hd__decap_3
XFILLER_85_623 VGND VGND VPWR VPWR sky130_fd_sc_hd__decap_3
XFILLER_97_483 VGND VGND VPWR VPWR sky130_fd_sc_hd__decap_3
Xhold1302 _7226_/Q VGND VGND VPWR VPWR _5205_/A sky130_fd_sc_hd__dlygate4sd3_1
Xhold1313 _7155_/Q VGND VGND VPWR VPWR _5352_/A0 sky130_fd_sc_hd__dlygate4sd3_1
Xhold1324 _7284_/Q VGND VGND VPWR VPWR _4593_/A sky130_fd_sc_hd__dlygate4sd3_1
X_5116_ _5110_/Y _5111_/X _5115_/X VGND VGND VPWR VPWR _5658_/D sky130_fd_sc_hd__o21ai_2
XFILLER_111_293 VGND VGND VPWR VPWR sky130_fd_sc_hd__decap_3
XFILLER_27_26 VGND VGND VPWR VPWR sky130_fd_sc_hd__decap_3
XFILLER_57_358 VGND VGND VPWR VPWR sky130_fd_sc_hd__fill_2
XFILLER_84_133 VGND VGND VPWR VPWR sky130_fd_sc_hd__decap_3
XFILLER_84_144 VGND VGND VPWR VPWR sky130_fd_sc_hd__fill_1
XFILLER_85_656 VGND VGND VPWR VPWR sky130_fd_sc_hd__decap_3
X_5047_ _5114_/B _4617_/B _4617_/C _5100_/A VGND VGND VPWR VPWR _5047_/Y sky130_fd_sc_hd__o31ai_2
XFILLER_26_701 VGND VGND VPWR VPWR sky130_fd_sc_hd__decap_3
XFILLER_38_550 VGND VGND VPWR VPWR sky130_fd_sc_hd__decap_3
XFILLER_84_188 VGND VGND VPWR VPWR sky130_fd_sc_hd__decap_3
XFILLER_25_222 VGND VGND VPWR VPWR sky130_fd_sc_hd__fill_2
XFILLER_72_339 VGND VGND VPWR VPWR sky130_fd_sc_hd__fill_2
X_6998_ _7373_/CLK _6998_/D _6278_/Y VGND VGND VPWR VPWR _6998_/Q sky130_fd_sc_hd__dfrtp_2
XFILLER_25_277 VGND VGND VPWR VPWR sky130_fd_sc_hd__decap_3
XFILLER_40_203 VGND VGND VPWR VPWR sky130_fd_sc_hd__decap_3
XFILLER_80_383 VGND VGND VPWR VPWR sky130_fd_sc_hd__decap_3
XFILLER_40_236 VGND VGND VPWR VPWR sky130_fd_sc_hd__decap_3
XFILLER_107_500 VGND VGND VPWR VPWR sky130_fd_sc_hd__decap_3
XFILLER_5_638 VGND VGND VPWR VPWR sky130_fd_sc_hd__decap_3
XFILLER_104_3 VGND VGND VPWR VPWR sky130_fd_sc_hd__decap_3
XFILLER_119_393 VGND VGND VPWR VPWR sky130_fd_sc_hd__fill_1
XFILLER_108_62 VGND VGND VPWR VPWR sky130_fd_sc_hd__decap_3
XFILLER_0_321 VGND VGND VPWR VPWR sky130_fd_sc_hd__fill_1
XFILLER_0_343 VGND VGND VPWR VPWR sky130_fd_sc_hd__decap_3
XFILLER_0_354 VGND VGND VPWR VPWR sky130_fd_sc_hd__decap_3
XFILLER_88_450 VGND VGND VPWR VPWR sky130_fd_sc_hd__decap_3
XFILLER_0_365 VGND VGND VPWR VPWR sky130_fd_sc_hd__decap_3
XFILLER_102_271 VGND VGND VPWR VPWR sky130_fd_sc_hd__decap_3
XFILLER_48_303 VGND VGND VPWR VPWR sky130_fd_sc_hd__decap_3
XFILLER_68_88 VGND VGND VPWR VPWR sky130_fd_sc_hd__decap_3
XFILLER_76_612 VGND VGND VPWR VPWR sky130_fd_sc_hd__decap_3
XFILLER_88_472 VGND VGND VPWR VPWR sky130_fd_sc_hd__decap_3
XFILLER_88_483 VGND VGND VPWR VPWR sky130_fd_sc_hd__decap_3
XFILLER_75_144 VGND VGND VPWR VPWR sky130_fd_sc_hd__decap_3
XFILLER_76_645 VGND VGND VPWR VPWR sky130_fd_sc_hd__decap_3
XFILLER_76_678 VGND VGND VPWR VPWR sky130_fd_sc_hd__decap_3
XFILLER_91_604 VGND VGND VPWR VPWR sky130_fd_sc_hd__decap_3
XFILLER_17_712 VGND VGND VPWR VPWR sky130_fd_sc_hd__fill_2
XFILLER_29_561 VGND VGND VPWR VPWR sky130_fd_sc_hd__decap_3
XFILLER_63_328 VGND VGND VPWR VPWR sky130_fd_sc_hd__decap_3
XFILLER_84_54 VGND VGND VPWR VPWR sky130_fd_sc_hd__decap_3
XFILLER_91_626 VGND VGND VPWR VPWR sky130_fd_sc_hd__decap_3
XFILLER_16_200 VGND VGND VPWR VPWR sky130_fd_sc_hd__decap_3
XFILLER_16_222 VGND VGND VPWR VPWR sky130_fd_sc_hd__decap_3
XFILLER_29_594 VGND VGND VPWR VPWR sky130_fd_sc_hd__decap_3
XFILLER_44_531 VGND VGND VPWR VPWR sky130_fd_sc_hd__fill_1
XFILLER_75_199 VGND VGND VPWR VPWR sky130_fd_sc_hd__decap_3
XFILLER_90_147 VGND VGND VPWR VPWR sky130_fd_sc_hd__decap_3
XFILLER_91_659 VGND VGND VPWR VPWR sky130_fd_sc_hd__decap_3
Xplace328 _3665_/X VGND VGND VPWR VPWR _3883_/B1 sky130_fd_sc_hd__buf_2
Xplace317 _4927_/C VGND VGND VPWR VPWR _5656_/C sky130_fd_sc_hd__buf_2
XFILLER_17_81 VGND VGND VPWR VPWR sky130_fd_sc_hd__decap_3
XFILLER_32_704 VGND VGND VPWR VPWR sky130_fd_sc_hd__decap_3
XFILLER_71_361 VGND VGND VPWR VPWR sky130_fd_sc_hd__fill_1
Xplace339 _3887_/A2 VGND VGND VPWR VPWR _3893_/B1 sky130_fd_sc_hd__buf_2
XFILLER_16_277 VGND VGND VPWR VPWR sky130_fd_sc_hd__decap_3
XFILLER_31_225 VGND VGND VPWR VPWR sky130_fd_sc_hd__decap_3
XFILLER_44_586 VGND VGND VPWR VPWR sky130_fd_sc_hd__fill_2
XTAP_TAPCELL_ROW_14_434 VGND VPWR sky130_fd_sc_hd__tapvpwrvgnd_1
XFILLER_31_269 VGND VGND VPWR VPWR sky130_fd_sc_hd__fill_2
XTAP_TAPCELL_ROW_42_787 VGND VPWR sky130_fd_sc_hd__tapvpwrvgnd_1
XFILLER_12_483 VGND VGND VPWR VPWR sky130_fd_sc_hd__decap_3
XTAP_TAPCELL_ROW_117_1720 VGND VPWR sky130_fd_sc_hd__tapvpwrvgnd_1
XFILLER_4_660 VGND VGND VPWR VPWR sky130_fd_sc_hd__decap_3
X_3300_ _5129_/B VGND VGND VPWR VPWR _4467_/A sky130_fd_sc_hd__inv_2
XFILLER_113_525 VGND VGND VPWR VPWR sky130_fd_sc_hd__fill_2
XFILLER_4_693 VGND VGND VPWR VPWR sky130_fd_sc_hd__decap_3
XFILLER_98_225 VGND VGND VPWR VPWR sky130_fd_sc_hd__decap_3
X_4280_ _7222_/Q _3377_/X _4339_/B1 _7158_/Q _4279_/X VGND VGND VPWR VPWR _4280_/X
+ sky130_fd_sc_hd__a221o_2
XFILLER_101_709 VGND VGND VPWR VPWR sky130_fd_sc_hd__decap_3
XFILLER_67_612 VGND VGND VPWR VPWR sky130_fd_sc_hd__decap_3
XFILLER_67_623 VGND VGND VPWR VPWR sky130_fd_sc_hd__decap_3
XFILLER_79_494 VGND VGND VPWR VPWR sky130_fd_sc_hd__fill_1
XFILLER_66_144 VGND VGND VPWR VPWR sky130_fd_sc_hd__decap_3
XFILLER_67_656 VGND VGND VPWR VPWR sky130_fd_sc_hd__decap_3
XFILLER_66_155 VGND VGND VPWR VPWR sky130_fd_sc_hd__decap_3
XFILLER_66_177 VGND VGND VPWR VPWR sky130_fd_sc_hd__fill_1
XFILLER_82_637 VGND VGND VPWR VPWR sky130_fd_sc_hd__decap_3
XTAP_TAPCELL_ROW_68_1107 VGND VPWR sky130_fd_sc_hd__tapvpwrvgnd_1
XFILLER_35_520 VGND VGND VPWR VPWR sky130_fd_sc_hd__fill_2
XFILLER_66_188 VGND VGND VPWR VPWR sky130_fd_sc_hd__decap_3
XFILLER_81_125 VGND VGND VPWR VPWR sky130_fd_sc_hd__decap_3
XFILLER_82_648 VGND VGND VPWR VPWR sky130_fd_sc_hd__decap_3
X_6921_ _6922_/CLK _6921_/D VGND VGND VPWR VPWR _6921_/Q sky130_fd_sc_hd__dfxtp_2
XFILLER_81_158 VGND VGND VPWR VPWR sky130_fd_sc_hd__decap_3
XFILLER_81_169 VGND VGND VPWR VPWR sky130_fd_sc_hd__decap_3
X_6852_ clkload9/A _6852_/D VGND VGND VPWR VPWR _6852_/Q sky130_fd_sc_hd__dfxtp_2
XFILLER_35_597 VGND VGND VPWR VPWR sky130_fd_sc_hd__decap_3
XFILLER_62_372 VGND VGND VPWR VPWR sky130_fd_sc_hd__decap_3
XFILLER_90_681 VGND VGND VPWR VPWR sky130_fd_sc_hd__decap_3
X_6783_ _6942_/CLK _6783_/D VGND VGND VPWR VPWR _6783_/Q sky130_fd_sc_hd__dfxtp_2
XFILLER_13_28 VGND VGND VPWR VPWR sky130_fd_sc_hd__fill_1
XFILLER_50_578 VGND VGND VPWR VPWR sky130_fd_sc_hd__fill_2
XFILLER_50_589 VGND VGND VPWR VPWR sky130_fd_sc_hd__fill_1
X_5665_ _5665_/A _5665_/B _5665_/C _5665_/D VGND VGND VPWR VPWR _5666_/B sky130_fd_sc_hd__and4_2
XFILLER_108_319 VGND VGND VPWR VPWR sky130_fd_sc_hd__decap_3
X_7404_ _7406_/CLK _7404_/D _6684_/Y VGND VGND VPWR VPWR _7404_/Q sky130_fd_sc_hd__dfrtp_2
X_4616_ _3547_/A _3547_/B _4614_/X _4615_/Y VGND VGND VPWR VPWR _4617_/C sky130_fd_sc_hd__a31o_2
XTAP_TAPCELL_ROW_79_1247 VGND VPWR sky130_fd_sc_hd__tapvpwrvgnd_1
X_7335_ _7406_/CLK _7335_/D _6615_/Y VGND VGND VPWR VPWR _7335_/Q sky130_fd_sc_hd__dfrtp_2
XTAP_TAPCELL_ROW_92_1403 VGND VPWR sky130_fd_sc_hd__tapvpwrvgnd_1
XPHY_EDGE_ROW_111_Right_111 VGND VGND VPWR VPWR sky130_fd_sc_hd__decap_3
XFILLER_2_619 VGND VGND VPWR VPWR sky130_fd_sc_hd__decap_3
XTAP_TAPCELL_ROW_92_1414 VGND VPWR sky130_fd_sc_hd__tapvpwrvgnd_1
XFILLER_104_525 VGND VGND VPWR VPWR sky130_fd_sc_hd__decap_3
XFILLER_104_536 VGND VGND VPWR VPWR sky130_fd_sc_hd__decap_3
XFILLER_104_547 VGND VGND VPWR VPWR sky130_fd_sc_hd__decap_3
XFILLER_89_214 VGND VGND VPWR VPWR sky130_fd_sc_hd__fill_1
XFILLER_89_225 VGND VGND VPWR VPWR sky130_fd_sc_hd__decap_3
X_7266_ _7362_/CLK _7266_/D _6546_/Y VGND VGND VPWR VPWR _7266_/Q sky130_fd_sc_hd__dfrtp_2
X_4478_ _7340_/Q _7308_/Q _4497_/S VGND VGND VPWR VPWR _7340_/D sky130_fd_sc_hd__mux2_2
X_7197_ _7358_/CLK _7197_/D _6477_/Y VGND VGND VPWR VPWR _7197_/Q sky130_fd_sc_hd__dfrtp_2
X_3429_ _3429_/A _3429_/B VGND VGND VPWR VPWR _3590_/A sky130_fd_sc_hd__or2_2
XFILLER_112_580 VGND VGND VPWR VPWR sky130_fd_sc_hd__decap_3
XFILLER_57_111 VGND VGND VPWR VPWR sky130_fd_sc_hd__fill_1
XFILLER_58_634 VGND VGND VPWR VPWR sky130_fd_sc_hd__decap_3
XFILLER_85_420 VGND VGND VPWR VPWR sky130_fd_sc_hd__decap_3
XFILLER_57_122 VGND VGND VPWR VPWR sky130_fd_sc_hd__fill_2
XFILLER_58_645 VGND VGND VPWR VPWR sky130_fd_sc_hd__decap_3
Xhold1110 _7382_/Q VGND VGND VPWR VPWR _3897_/A1 sky130_fd_sc_hd__dlygate4sd3_1
Xhold1121 _7259_/Q VGND VGND VPWR VPWR _5041_/A0 sky130_fd_sc_hd__dlygate4sd3_1
Xhold1132 _7197_/Q VGND VGND VPWR VPWR _5266_/A0 sky130_fd_sc_hd__dlygate4sd3_1
XFILLER_57_166 VGND VGND VPWR VPWR sky130_fd_sc_hd__fill_2
XFILLER_58_678 VGND VGND VPWR VPWR sky130_fd_sc_hd__decap_3
XFILLER_73_626 VGND VGND VPWR VPWR sky130_fd_sc_hd__decap_3
XFILLER_85_464 VGND VGND VPWR VPWR sky130_fd_sc_hd__fill_1
XFILLER_85_486 VGND VGND VPWR VPWR sky130_fd_sc_hd__fill_1
Xhold1143 _7241_/Q VGND VGND VPWR VPWR _5173_/A sky130_fd_sc_hd__dlygate4sd3_1
Xhold1154 _7388_/Q VGND VGND VPWR VPWR _3833_/A0 sky130_fd_sc_hd__dlygate4sd3_1
Xhold1165 _7347_/Q VGND VGND VPWR VPWR _5682_/A0 sky130_fd_sc_hd__dlygate4sd3_1
Xhold1176 _7312_/Q VGND VGND VPWR VPWR _4534_/A0 sky130_fd_sc_hd__dlygate4sd3_1
XFILLER_45_328 VGND VGND VPWR VPWR sky130_fd_sc_hd__decap_3
XFILLER_57_188 VGND VGND VPWR VPWR sky130_fd_sc_hd__decap_3
XFILLER_72_136 VGND VGND VPWR VPWR sky130_fd_sc_hd__decap_3
XFILLER_73_659 VGND VGND VPWR VPWR sky130_fd_sc_hd__decap_3
Xhold1187 _7337_/Q VGND VGND VPWR VPWR _4484_/A0 sky130_fd_sc_hd__dlygate4sd3_1
Xhold1198 _4488_/X VGND VGND VPWR VPWR _7335_/D sky130_fd_sc_hd__dlygate4sd3_1
XFILLER_14_704 VGND VGND VPWR VPWR sky130_fd_sc_hd__decap_3
XFILLER_54_24 VGND VGND VPWR VPWR sky130_fd_sc_hd__decap_3
XFILLER_54_46 VGND VGND VPWR VPWR sky130_fd_sc_hd__fill_2
XFILLER_60_309 VGND VGND VPWR VPWR sky130_fd_sc_hd__decap_3
XFILLER_72_147 VGND VGND VPWR VPWR sky130_fd_sc_hd__decap_3
XFILLER_13_225 VGND VGND VPWR VPWR sky130_fd_sc_hd__fill_2
XFILLER_26_575 VGND VGND VPWR VPWR sky130_fd_sc_hd__fill_2
XFILLER_41_534 VGND VGND VPWR VPWR sky130_fd_sc_hd__decap_3
XFILLER_110_41 VGND VGND VPWR VPWR sky130_fd_sc_hd__decap_3
XFILLER_41_556 VGND VGND VPWR VPWR sky130_fd_sc_hd__decap_3
XTAP_TAPCELL_ROW_101_1521 VGND VPWR sky130_fd_sc_hd__tapvpwrvgnd_1
XPHY_EDGE_ROW_109_Left_229 VGND VGND VPWR VPWR sky130_fd_sc_hd__decap_3
XFILLER_110_74 VGND VGND VPWR VPWR sky130_fd_sc_hd__decap_3
XFILLER_110_85 VGND VGND VPWR VPWR sky130_fd_sc_hd__decap_3
XFILLER_21_291 VGND VGND VPWR VPWR sky130_fd_sc_hd__decap_3
XFILLER_107_330 VGND VGND VPWR VPWR sky130_fd_sc_hd__decap_3
XFILLER_119_72 VGND VGND VPWR VPWR sky130_fd_sc_hd__decap_3
XFILLER_107_352 VGND VGND VPWR VPWR sky130_fd_sc_hd__decap_3
XFILLER_107_385 VGND VGND VPWR VPWR sky130_fd_sc_hd__decap_3
XFILLER_79_87 VGND VGND VPWR VPWR sky130_fd_sc_hd__decap_3
XPHY_EDGE_ROW_118_Left_238 VGND VGND VPWR VPWR sky130_fd_sc_hd__decap_3
XFILLER_1_641 VGND VGND VPWR VPWR sky130_fd_sc_hd__decap_3
XFILLER_96_707 VGND VGND VPWR VPWR sky130_fd_sc_hd__decap_3
XTAP_TAPCELL_ROW_112_1661 VGND VPWR sky130_fd_sc_hd__tapvpwrvgnd_1
XFILLER_110_539 VGND VGND VPWR VPWR sky130_fd_sc_hd__decap_3
XFILLER_1_685 VGND VGND VPWR VPWR sky130_fd_sc_hd__decap_3
XFILLER_49_623 VGND VGND VPWR VPWR sky130_fd_sc_hd__decap_3
XFILLER_48_133 VGND VGND VPWR VPWR sky130_fd_sc_hd__decap_3
XFILLER_48_144 VGND VGND VPWR VPWR sky130_fd_sc_hd__decap_3
XFILLER_49_656 VGND VGND VPWR VPWR sky130_fd_sc_hd__decap_3
XFILLER_76_453 VGND VGND VPWR VPWR sky130_fd_sc_hd__decap_3
XFILLER_95_75 VGND VGND VPWR VPWR sky130_fd_sc_hd__fill_2
XFILLER_48_166 VGND VGND VPWR VPWR sky130_fd_sc_hd__decap_3
XFILLER_64_604 VGND VGND VPWR VPWR sky130_fd_sc_hd__decap_3
XFILLER_76_486 VGND VGND VPWR VPWR sky130_fd_sc_hd__decap_3
XFILLER_91_412 VGND VGND VPWR VPWR sky130_fd_sc_hd__decap_3
XFILLER_29_391 VGND VGND VPWR VPWR sky130_fd_sc_hd__fill_1
XFILLER_63_125 VGND VGND VPWR VPWR sky130_fd_sc_hd__decap_3
XFILLER_64_637 VGND VGND VPWR VPWR sky130_fd_sc_hd__decap_3
XFILLER_64_648 VGND VGND VPWR VPWR sky130_fd_sc_hd__decap_3
XFILLER_91_445 VGND VGND VPWR VPWR sky130_fd_sc_hd__decap_3
XTAP_TAPCELL_ROW_47_846 VGND VPWR sky130_fd_sc_hd__tapvpwrvgnd_1
XFILLER_63_169 VGND VGND VPWR VPWR sky130_fd_sc_hd__decap_3
XFILLER_91_467 VGND VGND VPWR VPWR sky130_fd_sc_hd__fill_2
XFILLER_17_575 VGND VGND VPWR VPWR sky130_fd_sc_hd__decap_3
XFILLER_44_361 VGND VGND VPWR VPWR sky130_fd_sc_hd__decap_3
XFILLER_72_681 VGND VGND VPWR VPWR sky130_fd_sc_hd__decap_3
XFILLER_91_489 VGND VGND VPWR VPWR sky130_fd_sc_hd__decap_3
XFILLER_20_707 VGND VGND VPWR VPWR sky130_fd_sc_hd__decap_3
XFILLER_32_545 VGND VGND VPWR VPWR sky130_fd_sc_hd__fill_2
XTAP_TAPCELL_ROW_63_1048 VGND VPWR sky130_fd_sc_hd__tapvpwrvgnd_1
XTAP_TAPCELL_ROW_27_592 VGND VPWR sky130_fd_sc_hd__tapvpwrvgnd_1
XFILLER_32_589 VGND VGND VPWR VPWR sky130_fd_sc_hd__decap_3
X_3780_ _6967_/Q _3661_/X _3840_/A2 _6955_/Q VGND VGND VPWR VPWR _3780_/X sky130_fd_sc_hd__a22o_2
XFILLER_117_105 VGND VGND VPWR VPWR sky130_fd_sc_hd__decap_3
XFILLER_118_628 VGND VGND VPWR VPWR sky130_fd_sc_hd__decap_3
XFILLER_117_149 VGND VGND VPWR VPWR sky130_fd_sc_hd__decap_3
XFILLER_8_284 VGND VGND VPWR VPWR sky130_fd_sc_hd__decap_3
X_4401_ _7274_/Q _4437_/A2 _4430_/A2 _7242_/Q _4400_/X VGND VGND VPWR VPWR _4401_/X
+ sky130_fd_sc_hd__a221o_2
X_5381_ _5381_/A0 _4864_/X _5390_/S VGND VGND VPWR VPWR _7142_/D sky130_fd_sc_hd__mux2_2
XFILLER_99_501 VGND VGND VPWR VPWR sky130_fd_sc_hd__decap_3
X_7120_ _7344_/CLK _7120_/D _6400_/Y VGND VGND VPWR VPWR _7120_/Q sky130_fd_sc_hd__dfrtp_2
X_4332_ _7191_/Q _4471_/S _4354_/B1 _7383_/Q _4331_/X VGND VGND VPWR VPWR _4332_/X
+ sky130_fd_sc_hd__a221o_2
X_7051_ _7400_/CLK _7051_/D _6331_/Y VGND VGND VPWR VPWR _7051_/Q sky130_fd_sc_hd__dfrtp_2
X_4263_ _7134_/Q _4263_/A2 _4261_/X _4262_/X VGND VGND VPWR VPWR _4264_/B sky130_fd_sc_hd__a211o_2
XTAP_TAPCELL_ROW_74_1188 VGND VPWR sky130_fd_sc_hd__tapvpwrvgnd_1
XTAP_TAPCELL_ROW_74_1177 VGND VPWR sky130_fd_sc_hd__tapvpwrvgnd_1
XFILLER_86_206 VGND VGND VPWR VPWR sky130_fd_sc_hd__decap_3
XFILLER_86_239 VGND VGND VPWR VPWR sky130_fd_sc_hd__decap_3
XFILLER_67_420 VGND VGND VPWR VPWR sky130_fd_sc_hd__decap_3
X_4194_ _7231_/Q _4353_/A2 _4422_/A2 _7017_/Q _4193_/X VGND VGND VPWR VPWR _4194_/X
+ sky130_fd_sc_hd__a221o_2
XFILLER_27_306 VGND VGND VPWR VPWR sky130_fd_sc_hd__decap_3
XFILLER_55_615 VGND VGND VPWR VPWR sky130_fd_sc_hd__fill_1
XFILLER_55_626 VGND VGND VPWR VPWR sky130_fd_sc_hd__decap_3
XFILLER_94_250 VGND VGND VPWR VPWR sky130_fd_sc_hd__fill_2
XFILLER_54_114 VGND VGND VPWR VPWR sky130_fd_sc_hd__decap_3
XFILLER_55_659 VGND VGND VPWR VPWR sky130_fd_sc_hd__decap_3
XFILLER_94_272 VGND VGND VPWR VPWR sky130_fd_sc_hd__decap_3
XFILLER_42_309 VGND VGND VPWR VPWR sky130_fd_sc_hd__decap_3
XFILLER_54_147 VGND VGND VPWR VPWR sky130_fd_sc_hd__decap_3
XFILLER_70_607 VGND VGND VPWR VPWR sky130_fd_sc_hd__decap_3
X_6904_ _6942_/CLK _6904_/D VGND VGND VPWR VPWR _6904_/Q sky130_fd_sc_hd__dfxtp_2
XFILLER_23_501 VGND VGND VPWR VPWR sky130_fd_sc_hd__decap_3
XFILLER_82_489 VGND VGND VPWR VPWR sky130_fd_sc_hd__decap_3
X_6835_ _6983_/CLK _6835_/D VGND VGND VPWR VPWR _6835_/Q sky130_fd_sc_hd__dfxtp_2
XFILLER_10_206 VGND VGND VPWR VPWR sky130_fd_sc_hd__decap_3
X_6766_ _6968_/CLK _6766_/D VGND VGND VPWR VPWR _6766_/Q sky130_fd_sc_hd__dfxtp_2
X_5717_ _7364_/Q _5717_/A1 _5735_/S VGND VGND VPWR VPWR _6708_/D sky130_fd_sc_hd__mux2_2
XFILLER_109_617 VGND VGND VPWR VPWR sky130_fd_sc_hd__decap_3
X_6697_ _6923_/CLK _6697_/D VGND VGND VPWR VPWR _6697_/Q sky130_fd_sc_hd__dfxtp_2
X_5648_ _5648_/A _5648_/B VGND VGND VPWR VPWR _5649_/A sky130_fd_sc_hd__or2_2
XFILLER_117_650 VGND VGND VPWR VPWR sky130_fd_sc_hd__decap_3
X_5579_ _5579_/A0 _5045_/X _5579_/S VGND VGND VPWR VPWR _7039_/D sky130_fd_sc_hd__mux2_2
XFILLER_116_171 VGND VGND VPWR VPWR sky130_fd_sc_hd__decap_3
XFILLER_117_694 VGND VGND VPWR VPWR sky130_fd_sc_hd__decap_3
X_7318_ _7350_/CLK _7318_/D _6598_/Y VGND VGND VPWR VPWR _7318_/Q sky130_fd_sc_hd__dfrtp_2
XFILLER_104_333 VGND VGND VPWR VPWR sky130_fd_sc_hd__decap_3
XFILLER_78_707 VGND VGND VPWR VPWR sky130_fd_sc_hd__decap_3
X_7249_ _7313_/CLK _7249_/D _6529_/Y VGND VGND VPWR VPWR _7249_/Q sky130_fd_sc_hd__dfrtp_2
XFILLER_104_377 VGND VGND VPWR VPWR sky130_fd_sc_hd__decap_3
XFILLER_49_57 VGND VGND VPWR VPWR sky130_fd_sc_hd__decap_3
XFILLER_77_228 VGND VGND VPWR VPWR sky130_fd_sc_hd__decap_3
XFILLER_105_52 VGND VGND VPWR VPWR sky130_fd_sc_hd__decap_3
XFILLER_105_74 VGND VGND VPWR VPWR sky130_fd_sc_hd__decap_3
XFILLER_46_604 VGND VGND VPWR VPWR sky130_fd_sc_hd__decap_3
XFILLER_58_475 VGND VGND VPWR VPWR sky130_fd_sc_hd__fill_1
XFILLER_100_583 VGND VGND VPWR VPWR sky130_fd_sc_hd__decap_3
XFILLER_46_637 VGND VGND VPWR VPWR sky130_fd_sc_hd__decap_3
XFILLER_46_648 VGND VGND VPWR VPWR sky130_fd_sc_hd__decap_3
XFILLER_73_445 VGND VGND VPWR VPWR sky130_fd_sc_hd__decap_3
XTAP_TAPCELL_ROW_44_805 VGND VPWR sky130_fd_sc_hd__tapvpwrvgnd_1
XFILLER_54_681 VGND VGND VPWR VPWR sky130_fd_sc_hd__decap_3
XFILLER_60_128 VGND VGND VPWR VPWR sky130_fd_sc_hd__decap_3
XFILLER_61_629 VGND VGND VPWR VPWR sky130_fd_sc_hd__decap_3
XFILLER_41_320 VGND VGND VPWR VPWR sky130_fd_sc_hd__decap_3
XFILLER_53_191 VGND VGND VPWR VPWR sky130_fd_sc_hd__decap_3
XFILLER_14_567 VGND VGND VPWR VPWR sky130_fd_sc_hd__decap_3
XFILLER_14_589 VGND VGND VPWR VPWR sky130_fd_sc_hd__decap_3
XFILLER_81_55 VGND VGND VPWR VPWR sky130_fd_sc_hd__fill_1
XFILLER_81_66 VGND VGND VPWR VPWR sky130_fd_sc_hd__decap_3
XTAP_TAPCELL_ROW_24_562 VGND VPWR sky130_fd_sc_hd__tapvpwrvgnd_1
XFILLER_14_82 VGND VGND VPWR VPWR sky130_fd_sc_hd__fill_2
XFILLER_108_672 VGND VGND VPWR VPWR sky130_fd_sc_hd__decap_3
XFILLER_5_254 VGND VGND VPWR VPWR sky130_fd_sc_hd__fill_2
XFILLER_5_287 VGND VGND VPWR VPWR sky130_fd_sc_hd__decap_3
XFILLER_107_193 VGND VGND VPWR VPWR sky130_fd_sc_hd__decap_3
XFILLER_1_460 VGND VGND VPWR VPWR sky130_fd_sc_hd__decap_3
XFILLER_1_493 VGND VGND VPWR VPWR sky130_fd_sc_hd__decap_3
XFILLER_96_548 VGND VGND VPWR VPWR sky130_fd_sc_hd__decap_3
XFILLER_92_710 VGND VGND VPWR VPWR sky130_fd_sc_hd__decap_3
XFILLER_37_626 VGND VGND VPWR VPWR sky130_fd_sc_hd__decap_3
XFILLER_37_659 VGND VGND VPWR VPWR sky130_fd_sc_hd__decap_3
XFILLER_36_147 VGND VGND VPWR VPWR sky130_fd_sc_hd__decap_3
XFILLER_36_158 VGND VGND VPWR VPWR sky130_fd_sc_hd__decap_3
XFILLER_91_231 VGND VGND VPWR VPWR sky130_fd_sc_hd__fill_1
XFILLER_91_242 VGND VGND VPWR VPWR sky130_fd_sc_hd__decap_3
XFILLER_51_128 VGND VGND VPWR VPWR sky130_fd_sc_hd__decap_3
XFILLER_64_489 VGND VGND VPWR VPWR sky130_fd_sc_hd__decap_3
XFILLER_91_297 VGND VGND VPWR VPWR sky130_fd_sc_hd__decap_3
X_4950_ _4950_/A _4950_/B VGND VGND VPWR VPWR _4950_/Y sky130_fd_sc_hd__nor2_2
XFILLER_60_640 VGND VGND VPWR VPWR sky130_fd_sc_hd__decap_3
X_4881_ _6998_/Q _4912_/A VGND VGND VPWR VPWR _4882_/B sky130_fd_sc_hd__or2_2
X_3901_ _3901_/A1 _5104_/A _3900_/Y VGND VGND VPWR VPWR _7381_/D sky130_fd_sc_hd__a21bo_2
XFILLER_20_504 VGND VGND VPWR VPWR sky130_fd_sc_hd__decap_3
XFILLER_60_651 VGND VGND VPWR VPWR sky130_fd_sc_hd__decap_3
XFILLER_60_684 VGND VGND VPWR VPWR sky130_fd_sc_hd__decap_3
X_6620_ _6621_/A VGND VGND VPWR VPWR _6620_/Y sky130_fd_sc_hd__inv_2
X_3832_ _3728_/Y _3824_/X _3826_/X _3735_/X _3831_/X VGND VGND VPWR VPWR _3832_/X
+ sky130_fd_sc_hd__a221o_2
X_6551_ _6651_/A VGND VGND VPWR VPWR _6551_/Y sky130_fd_sc_hd__inv_2
XFILLER_20_559 VGND VGND VPWR VPWR sky130_fd_sc_hd__decap_3
X_3763_ _3763_/A1 _3857_/A2 _3762_/X VGND VGND VPWR VPWR _7395_/D sky130_fd_sc_hd__a21o_2
XFILLER_118_447 VGND VGND VPWR VPWR sky130_fd_sc_hd__fill_2
XFILLER_118_458 VGND VGND VPWR VPWR sky130_fd_sc_hd__decap_3
X_6482_ _6680_/A VGND VGND VPWR VPWR _6482_/Y sky130_fd_sc_hd__inv_2
XTAP_TAPCELL_ROW_76_1206 VGND VPWR sky130_fd_sc_hd__tapvpwrvgnd_1
XFILLER_9_582 VGND VGND VPWR VPWR sky130_fd_sc_hd__decap_3
XFILLER_105_108 VGND VGND VPWR VPWR sky130_fd_sc_hd__decap_3
XFILLER_105_119 VGND VGND VPWR VPWR sky130_fd_sc_hd__decap_3
XFILLER_114_631 VGND VGND VPWR VPWR sky130_fd_sc_hd__decap_3
X_7103_ _7360_/CLK _7103_/D _6383_/Y VGND VGND VPWR VPWR _7103_/Q sky130_fd_sc_hd__dfrtp_2
X_4315_ _4315_/A _4315_/B VGND VGND VPWR VPWR _4619_/A sky130_fd_sc_hd__nand2_2
XFILLER_113_141 VGND VGND VPWR VPWR sky130_fd_sc_hd__decap_3
XFILLER_113_163 VGND VGND VPWR VPWR sky130_fd_sc_hd__decap_3
XFILLER_113_174 VGND VGND VPWR VPWR sky130_fd_sc_hd__decap_3
XFILLER_114_675 VGND VGND VPWR VPWR sky130_fd_sc_hd__decap_3
XFILLER_87_559 VGND VGND VPWR VPWR sky130_fd_sc_hd__fill_1
X_7034_ _7349_/CLK _7034_/D _6314_/Y VGND VGND VPWR VPWR _7034_/Q sky130_fd_sc_hd__dfrtp_2
X_4246_ _7229_/Q _4349_/B1 _4263_/A2 _7133_/Q VGND VGND VPWR VPWR _4246_/X sky130_fd_sc_hd__a22o_2
XFILLER_101_358 VGND VGND VPWR VPWR sky130_fd_sc_hd__decap_3
XFILLER_28_604 VGND VGND VPWR VPWR sky130_fd_sc_hd__decap_3
XFILLER_74_209 VGND VGND VPWR VPWR sky130_fd_sc_hd__decap_3
X_4177_ _7232_/Q _4421_/A2 _4175_/X _4176_/X VGND VGND VPWR VPWR _4177_/X sky130_fd_sc_hd__a211o_2
XFILLER_27_125 VGND VGND VPWR VPWR sky130_fd_sc_hd__decap_3
XFILLER_28_637 VGND VGND VPWR VPWR sky130_fd_sc_hd__decap_3
XFILLER_28_648 VGND VGND VPWR VPWR sky130_fd_sc_hd__decap_3
XFILLER_82_253 VGND VGND VPWR VPWR sky130_fd_sc_hd__decap_3
XTAP_TAPCELL_ROW_87_1346 VGND VPWR sky130_fd_sc_hd__tapvpwrvgnd_1
XTAP_TAPCELL_ROW_2_279 VGND VPWR sky130_fd_sc_hd__tapvpwrvgnd_1
XFILLER_27_169 VGND VGND VPWR VPWR sky130_fd_sc_hd__decap_3
XFILLER_36_681 VGND VGND VPWR VPWR sky130_fd_sc_hd__decap_3
XFILLER_43_629 VGND VGND VPWR VPWR sky130_fd_sc_hd__decap_3
XFILLER_55_478 VGND VGND VPWR VPWR sky130_fd_sc_hd__decap_3
XFILLER_23_331 VGND VGND VPWR VPWR sky130_fd_sc_hd__decap_3
XFILLER_42_128 VGND VGND VPWR VPWR sky130_fd_sc_hd__decap_3
XFILLER_23_353 VGND VGND VPWR VPWR sky130_fd_sc_hd__decap_3
XFILLER_51_662 VGND VGND VPWR VPWR sky130_fd_sc_hd__decap_3
XFILLER_51_673 VGND VGND VPWR VPWR sky130_fd_sc_hd__decap_3
X_6818_ clkload3/A _6818_/D VGND VGND VPWR VPWR _6818_/Q sky130_fd_sc_hd__dfxtp_2
XFILLER_50_194 VGND VGND VPWR VPWR sky130_fd_sc_hd__fill_2
XTAP_TAPCELL_ROW_21_521 VGND VPWR sky130_fd_sc_hd__tapvpwrvgnd_1
XFILLER_11_559 VGND VGND VPWR VPWR sky130_fd_sc_hd__fill_1
XFILLER_7_508 VGND VGND VPWR VPWR sky130_fd_sc_hd__decap_3
X_6749_ _6923_/CLK _6749_/D VGND VGND VPWR VPWR _6749_/Q sky130_fd_sc_hd__dfxtp_2
XFILLER_109_447 VGND VGND VPWR VPWR sky130_fd_sc_hd__fill_1
XFILLER_3_703 VGND VGND VPWR VPWR sky130_fd_sc_hd__decap_3
XTAP_TAPCELL_ROW_98_1486 VGND VPWR sky130_fd_sc_hd__tapvpwrvgnd_1
XFILLER_105_620 VGND VGND VPWR VPWR sky130_fd_sc_hd__decap_3
XFILLER_105_653 VGND VGND VPWR VPWR sky130_fd_sc_hd__decap_3
XFILLER_104_141 VGND VGND VPWR VPWR sky130_fd_sc_hd__decap_3
XFILLER_104_174 VGND VGND VPWR VPWR sky130_fd_sc_hd__decap_3
XFILLER_105_697 VGND VGND VPWR VPWR sky130_fd_sc_hd__decap_3
XFILLER_78_526 VGND VGND VPWR VPWR sky130_fd_sc_hd__decap_3
XFILLER_116_62 VGND VGND VPWR VPWR sky130_fd_sc_hd__decap_3
XFILLER_78_548 VGND VGND VPWR VPWR sky130_fd_sc_hd__decap_3
XFILLER_19_604 VGND VGND VPWR VPWR sky130_fd_sc_hd__decap_3
XFILLER_65_209 VGND VGND VPWR VPWR sky130_fd_sc_hd__decap_3
XFILLER_76_55 VGND VGND VPWR VPWR sky130_fd_sc_hd__fill_1
XFILLER_18_103 VGND VGND VPWR VPWR sky130_fd_sc_hd__decap_3
XFILLER_19_626 VGND VGND VPWR VPWR sky130_fd_sc_hd__decap_3
XFILLER_46_401 VGND VGND VPWR VPWR sky130_fd_sc_hd__decap_3
XFILLER_58_261 VGND VGND VPWR VPWR sky130_fd_sc_hd__fill_1
XFILLER_58_272 VGND VGND VPWR VPWR sky130_fd_sc_hd__decap_3
XFILLER_58_294 VGND VGND VPWR VPWR sky130_fd_sc_hd__decap_3
XFILLER_74_710 VGND VGND VPWR VPWR sky130_fd_sc_hd__decap_3
XFILLER_76_88 VGND VGND VPWR VPWR sky130_fd_sc_hd__decap_3
XTAP_TAPCELL_ROW_29_621 VGND VPWR sky130_fd_sc_hd__tapvpwrvgnd_1
XFILLER_19_659 VGND VGND VPWR VPWR sky130_fd_sc_hd__decap_3
XFILLER_34_607 VGND VGND VPWR VPWR sky130_fd_sc_hd__decap_3
XFILLER_46_456 VGND VGND VPWR VPWR sky130_fd_sc_hd__decap_3
XFILLER_73_231 VGND VGND VPWR VPWR sky130_fd_sc_hd__decap_3
XFILLER_33_106 VGND VGND VPWR VPWR sky130_fd_sc_hd__decap_3
XFILLER_46_489 VGND VGND VPWR VPWR sky130_fd_sc_hd__decap_3
XFILLER_73_275 VGND VGND VPWR VPWR sky130_fd_sc_hd__decap_3
XFILLER_92_32 VGND VGND VPWR VPWR sky130_fd_sc_hd__decap_3
XTAP_TAPCELL_ROW_57_974 VGND VPWR sky130_fd_sc_hd__tapvpwrvgnd_1
XTAP_TAPCELL_ROW_107_1593 VGND VPWR sky130_fd_sc_hd__tapvpwrvgnd_1
XFILLER_25_81 VGND VGND VPWR VPWR sky130_fd_sc_hd__decap_3
XFILLER_42_651 VGND VGND VPWR VPWR sky130_fd_sc_hd__decap_3
XTAP_TAPCELL_ROW_60_1007 VGND VPWR sky130_fd_sc_hd__tapvpwrvgnd_1
XFILLER_14_375 VGND VGND VPWR VPWR sky130_fd_sc_hd__decap_3
XFILLER_41_183 VGND VGND VPWR VPWR sky130_fd_sc_hd__decap_3
XFILLER_42_684 VGND VGND VPWR VPWR sky130_fd_sc_hd__decap_3
XFILLER_10_581 VGND VGND VPWR VPWR sky130_fd_sc_hd__decap_3
XFILLER_10_592 VGND VGND VPWR VPWR sky130_fd_sc_hd__decap_3
XFILLER_115_406 VGND VGND VPWR VPWR sky130_fd_sc_hd__decap_3
XFILLER_6_563 VGND VGND VPWR VPWR sky130_fd_sc_hd__decap_3
XFILLER_108_480 VGND VGND VPWR VPWR sky130_fd_sc_hd__decap_3
XFILLER_111_612 VGND VGND VPWR VPWR sky130_fd_sc_hd__decap_3
XFILLER_69_526 VGND VGND VPWR VPWR sky130_fd_sc_hd__decap_3
XFILLER_110_100 VGND VGND VPWR VPWR sky130_fd_sc_hd__decap_3
XFILLER_111_623 VGND VGND VPWR VPWR sky130_fd_sc_hd__decap_3
XFILLER_111_656 VGND VGND VPWR VPWR sky130_fd_sc_hd__decap_3
X_5080_ _5080_/A0 _5079_/X _5080_/S VGND VGND VPWR VPWR _7257_/D sky130_fd_sc_hd__mux2_2
X_4100_ _7269_/Q _4131_/A2 _4421_/A2 _7237_/Q _4099_/X VGND VGND VPWR VPWR _4100_/X
+ sky130_fd_sc_hd__a221o_2
XTAP_TAPCELL_ROW_71_1147 VGND VPWR sky130_fd_sc_hd__tapvpwrvgnd_1
XFILLER_110_133 VGND VGND VPWR VPWR sky130_fd_sc_hd__decap_3
XFILLER_84_529 VGND VGND VPWR VPWR sky130_fd_sc_hd__decap_3
XFILLER_2_85 VGND VGND VPWR VPWR sky130_fd_sc_hd__decap_3
XFILLER_37_423 VGND VGND VPWR VPWR sky130_fd_sc_hd__decap_3
XFILLER_25_607 VGND VGND VPWR VPWR sky130_fd_sc_hd__decap_3
XFILLER_64_231 VGND VGND VPWR VPWR sky130_fd_sc_hd__fill_1
XFILLER_18_681 VGND VGND VPWR VPWR sky130_fd_sc_hd__decap_3
XFILLER_25_629 VGND VGND VPWR VPWR sky130_fd_sc_hd__decap_3
XFILLER_64_286 VGND VGND VPWR VPWR sky130_fd_sc_hd__fill_2
XFILLER_80_713 VGND VGND VPWR VPWR sky130_fd_sc_hd__fill_1
X_4933_ _4933_/A0 _4932_/X _4979_/S VGND VGND VPWR VPWR _7266_/D sky130_fd_sc_hd__mux2_2
XFILLER_33_662 VGND VGND VPWR VPWR sky130_fd_sc_hd__decap_3
XFILLER_33_673 VGND VGND VPWR VPWR sky130_fd_sc_hd__decap_3
XFILLER_32_172 VGND VGND VPWR VPWR sky130_fd_sc_hd__decap_3
X_4864_ _4910_/A _4857_/X _4860_/Y _7000_/D _5666_/A VGND VGND VPWR VPWR _4864_/X
+ sky130_fd_sc_hd__a32o_2
XTAP_TAPCELL_ROW_82_1287 VGND VPWR sky130_fd_sc_hd__tapvpwrvgnd_1
XFILLER_119_701 VGND VGND VPWR VPWR sky130_fd_sc_hd__decap_3
X_6603_ _6631_/A VGND VGND VPWR VPWR _6603_/Y sky130_fd_sc_hd__inv_2
X_4795_ _4795_/A _4795_/B VGND VGND VPWR VPWR _4795_/X sky130_fd_sc_hd__xor2_2
X_3815_ _6928_/Q _3912_/A2 _3913_/B1 _6702_/Q VGND VGND VPWR VPWR _3815_/X sky130_fd_sc_hd__a22o_2
XFILLER_118_200 VGND VGND VPWR VPWR sky130_fd_sc_hd__decap_3
X_6534_ _6598_/A VGND VGND VPWR VPWR _6534_/Y sky130_fd_sc_hd__inv_2
X_3746_ _3746_/A _3746_/B _3746_/C VGND VGND VPWR VPWR _3746_/X sky130_fd_sc_hd__and3_2
X_6465_ _6625_/A VGND VGND VPWR VPWR _6465_/Y sky130_fd_sc_hd__inv_2
XFILLER_106_439 VGND VGND VPWR VPWR sky130_fd_sc_hd__decap_3
X_3677_ _6942_/Q VGND VGND VPWR VPWR _3677_/Y sky130_fd_sc_hd__inv_2
X_6396_ _6652_/A VGND VGND VPWR VPWR _6396_/Y sky130_fd_sc_hd__inv_2
XFILLER_114_461 VGND VGND VPWR VPWR sky130_fd_sc_hd__decap_3
XFILLER_99_172 VGND VGND VPWR VPWR sky130_fd_sc_hd__fill_1
XFILLER_102_634 VGND VGND VPWR VPWR sky130_fd_sc_hd__decap_3
XFILLER_102_645 VGND VGND VPWR VPWR sky130_fd_sc_hd__decap_3
X_5278_ _5278_/A0 _5107_/X _5292_/S VGND VGND VPWR VPWR _7191_/D sky130_fd_sc_hd__mux2_2
XTAP_TAPCELL_ROW_7_349 VGND VPWR sky130_fd_sc_hd__tapvpwrvgnd_1
XFILLER_99_194 VGND VGND VPWR VPWR sky130_fd_sc_hd__decap_3
XFILLER_102_678 VGND VGND VPWR VPWR sky130_fd_sc_hd__decap_3
XFILLER_87_367 VGND VGND VPWR VPWR sky130_fd_sc_hd__decap_3
X_7017_ _7333_/CLK _7017_/D _6297_/Y VGND VGND VPWR VPWR _7017_/Q sky130_fd_sc_hd__dfrtp_2
X_4229_ _7099_/Q _4351_/A2 _4333_/A2 _7131_/Q VGND VGND VPWR VPWR _4229_/X sky130_fd_sc_hd__a22o_2
XFILLER_28_401 VGND VGND VPWR VPWR sky130_fd_sc_hd__decap_3
XFILLER_56_710 VGND VGND VPWR VPWR sky130_fd_sc_hd__decap_3
XFILLER_16_607 VGND VGND VPWR VPWR sky130_fd_sc_hd__decap_3
XFILLER_55_231 VGND VGND VPWR VPWR sky130_fd_sc_hd__decap_3
XFILLER_28_489 VGND VGND VPWR VPWR sky130_fd_sc_hd__decap_3
XFILLER_55_264 VGND VGND VPWR VPWR sky130_fd_sc_hd__decap_3
XFILLER_43_437 VGND VGND VPWR VPWR sky130_fd_sc_hd__decap_3
XFILLER_70_245 VGND VGND VPWR VPWR sky130_fd_sc_hd__decap_3
XTAP_TAPCELL_ROW_54_933 VGND VPWR sky130_fd_sc_hd__tapvpwrvgnd_1
XFILLER_102_97 VGND VGND VPWR VPWR sky130_fd_sc_hd__decap_3
XFILLER_24_640 VGND VGND VPWR VPWR sky130_fd_sc_hd__decap_3
XFILLER_24_651 VGND VGND VPWR VPWR sky130_fd_sc_hd__decap_3
XFILLER_62_46 VGND VGND VPWR VPWR sky130_fd_sc_hd__decap_3
XFILLER_70_267 VGND VGND VPWR VPWR sky130_fd_sc_hd__decap_3
XFILLER_11_301 VGND VGND VPWR VPWR sky130_fd_sc_hd__decap_3
XFILLER_11_323 VGND VGND VPWR VPWR sky130_fd_sc_hd__decap_3
XFILLER_24_684 VGND VGND VPWR VPWR sky130_fd_sc_hd__decap_3
XFILLER_7_305 VGND VGND VPWR VPWR sky130_fd_sc_hd__decap_3
XFILLER_109_255 VGND VGND VPWR VPWR sky130_fd_sc_hd__decap_3
XFILLER_7_349 VGND VGND VPWR VPWR sky130_fd_sc_hd__decap_3
XFILLER_109_299 VGND VGND VPWR VPWR sky130_fd_sc_hd__fill_1
XFILLER_3_511 VGND VGND VPWR VPWR sky130_fd_sc_hd__decap_3
XFILLER_3_544 VGND VGND VPWR VPWR sky130_fd_sc_hd__decap_3
XFILLER_105_461 VGND VGND VPWR VPWR sky130_fd_sc_hd__decap_3
XFILLER_3_588 VGND VGND VPWR VPWR sky130_fd_sc_hd__decap_3
XFILLER_78_312 VGND VGND VPWR VPWR sky130_fd_sc_hd__decap_3
XFILLER_38_209 VGND VGND VPWR VPWR sky130_fd_sc_hd__fill_2
XFILLER_78_378 VGND VGND VPWR VPWR sky130_fd_sc_hd__decap_3
XFILLER_59_570 VGND VGND VPWR VPWR sky130_fd_sc_hd__fill_1
XFILLER_93_337 VGND VGND VPWR VPWR sky130_fd_sc_hd__decap_3
XTAP_TAPCELL_ROW_109_1622 VGND VPWR sky130_fd_sc_hd__tapvpwrvgnd_1
XFILLER_46_242 VGND VGND VPWR VPWR sky130_fd_sc_hd__decap_3
XFILLER_19_467 VGND VGND VPWR VPWR sky130_fd_sc_hd__decap_3
XFILLER_46_253 VGND VGND VPWR VPWR sky130_fd_sc_hd__decap_3
XFILLER_46_264 VGND VGND VPWR VPWR sky130_fd_sc_hd__fill_2
XFILLER_62_713 VGND VGND VPWR VPWR sky130_fd_sc_hd__fill_1
XFILLER_46_286 VGND VGND VPWR VPWR sky130_fd_sc_hd__decap_3
XFILLER_15_662 VGND VGND VPWR VPWR sky130_fd_sc_hd__decap_3
XFILLER_15_673 VGND VGND VPWR VPWR sky130_fd_sc_hd__decap_3
XFILLER_21_109 VGND VGND VPWR VPWR sky130_fd_sc_hd__decap_3
XFILLER_61_245 VGND VGND VPWR VPWR sky130_fd_sc_hd__fill_2
XFILLER_14_150 VGND VGND VPWR VPWR sky130_fd_sc_hd__fill_1
XFILLER_30_610 VGND VGND VPWR VPWR sky130_fd_sc_hd__decap_3
XFILLER_99_6 VGND VGND VPWR VPWR sky130_fd_sc_hd__decap_3
XFILLER_30_643 VGND VGND VPWR VPWR sky130_fd_sc_hd__fill_1
XFILLER_30_654 VGND VGND VPWR VPWR sky130_fd_sc_hd__decap_3
XFILLER_30_687 VGND VGND VPWR VPWR sky130_fd_sc_hd__decap_3
X_3600_ _3600_/A VGND VGND VPWR VPWR _3600_/Y sky130_fd_sc_hd__inv_2
XFILLER_116_704 VGND VGND VPWR VPWR sky130_fd_sc_hd__decap_3
XFILLER_115_214 VGND VGND VPWR VPWR sky130_fd_sc_hd__decap_3
Xhold806 _6900_/Q VGND VGND VPWR VPWR _6900_/D sky130_fd_sc_hd__dlygate4sd3_1
Xhold817 _6730_/Q VGND VGND VPWR VPWR _6730_/D sky130_fd_sc_hd__dlygate4sd3_1
Xhold828 _6731_/Q VGND VGND VPWR VPWR _6731_/D sky130_fd_sc_hd__dlygate4sd3_1
XFILLER_115_225 VGND VGND VPWR VPWR sky130_fd_sc_hd__fill_2
Xhold839 _6891_/Q VGND VGND VPWR VPWR _6891_/D sky130_fd_sc_hd__dlygate4sd3_1
X_3462_ _7249_/Q _4599_/S _3459_/X _3461_/X VGND VGND VPWR VPWR _3462_/X sky130_fd_sc_hd__a211o_2
XFILLER_97_632 VGND VGND VPWR VPWR sky130_fd_sc_hd__decap_3
X_5132_ _5132_/A0 _5131_/X _5136_/S VGND VGND VPWR VPWR _7252_/D sky130_fd_sc_hd__mux2_2
XFILLER_69_367 VGND VGND VPWR VPWR sky130_fd_sc_hd__decap_3
XFILLER_96_131 VGND VGND VPWR VPWR sky130_fd_sc_hd__decap_3
XFILLER_96_153 VGND VGND VPWR VPWR sky130_fd_sc_hd__decap_3
XFILLER_97_665 VGND VGND VPWR VPWR sky130_fd_sc_hd__decap_3
XFILLER_97_676 VGND VGND VPWR VPWR sky130_fd_sc_hd__decap_3
XTAP_TAPCELL_ROW_4_308 VGND VPWR sky130_fd_sc_hd__tapvpwrvgnd_1
XFILLER_111_475 VGND VGND VPWR VPWR sky130_fd_sc_hd__fill_2
XFILLER_111_486 VGND VGND VPWR VPWR sky130_fd_sc_hd__decap_3
XFILLER_38_710 VGND VGND VPWR VPWR sky130_fd_sc_hd__decap_3
XFILLER_84_326 VGND VGND VPWR VPWR sky130_fd_sc_hd__decap_3
XFILLER_96_186 VGND VGND VPWR VPWR sky130_fd_sc_hd__decap_3
XFILLER_96_197 VGND VGND VPWR VPWR sky130_fd_sc_hd__decap_3
X_5063_ _5063_/A0 _5061_/X _5159_/S VGND VGND VPWR VPWR _7258_/D sky130_fd_sc_hd__mux2_2
XFILLER_37_242 VGND VGND VPWR VPWR sky130_fd_sc_hd__decap_3
XFILLER_65_551 VGND VGND VPWR VPWR sky130_fd_sc_hd__decap_3
XFILLER_25_404 VGND VGND VPWR VPWR sky130_fd_sc_hd__decap_3
XFILLER_80_510 VGND VGND VPWR VPWR sky130_fd_sc_hd__fill_2
XTAP_TAPCELL_ROW_84_1305 VGND VPWR sky130_fd_sc_hd__tapvpwrvgnd_1
XFILLER_65_595 VGND VGND VPWR VPWR sky130_fd_sc_hd__fill_1
XFILLER_40_418 VGND VGND VPWR VPWR sky130_fd_sc_hd__fill_2
XFILLER_52_245 VGND VGND VPWR VPWR sky130_fd_sc_hd__fill_1
XFILLER_52_267 VGND VGND VPWR VPWR sky130_fd_sc_hd__decap_3
X_4916_ _4916_/A _4916_/B VGND VGND VPWR VPWR _4967_/A sky130_fd_sc_hd__nand2_2
XFILLER_20_120 VGND VGND VPWR VPWR sky130_fd_sc_hd__fill_1
XFILLER_21_632 VGND VGND VPWR VPWR sky130_fd_sc_hd__decap_3
XFILLER_21_665 VGND VGND VPWR VPWR sky130_fd_sc_hd__decap_3
XFILLER_33_492 VGND VGND VPWR VPWR sky130_fd_sc_hd__decap_3
X_4847_ _4968_/A _4384_/C _4206_/X VGND VGND VPWR VPWR _4904_/B sky130_fd_sc_hd__a21oi_2
XFILLER_119_531 VGND VGND VPWR VPWR sky130_fd_sc_hd__fill_1
XFILLER_21_676 VGND VGND VPWR VPWR sky130_fd_sc_hd__decap_3
X_4778_ _4778_/A _4778_/B VGND VGND VPWR VPWR _4827_/B sky130_fd_sc_hd__and2_2
XFILLER_119_597 VGND VGND VPWR VPWR sky130_fd_sc_hd__decap_3
X_6517_ _6613_/A VGND VGND VPWR VPWR _6517_/Y sky130_fd_sc_hd__inv_2
X_3729_ _6968_/Q _3906_/A2 _3911_/B1 _6962_/Q VGND VGND VPWR VPWR _3729_/X sky130_fd_sc_hd__a22o_2
XTAP_TAPCELL_ROW_95_1445 VGND VPWR sky130_fd_sc_hd__tapvpwrvgnd_1
XFILLER_106_247 VGND VGND VPWR VPWR sky130_fd_sc_hd__decap_3
X_6448_ _6644_/A VGND VGND VPWR VPWR _6448_/Y sky130_fd_sc_hd__inv_2
X_6379_ _6571_/A VGND VGND VPWR VPWR _6379_/Y sky130_fd_sc_hd__inv_2
XFILLER_0_525 VGND VGND VPWR VPWR sky130_fd_sc_hd__decap_3
XFILLER_0_536 VGND VGND VPWR VPWR sky130_fd_sc_hd__fill_2
XFILLER_114_280 VGND VGND VPWR VPWR sky130_fd_sc_hd__decap_3
XFILLER_88_621 VGND VGND VPWR VPWR sky130_fd_sc_hd__decap_3
XFILLER_0_558 VGND VGND VPWR VPWR sky130_fd_sc_hd__fill_2
XFILLER_102_464 VGND VGND VPWR VPWR sky130_fd_sc_hd__decap_3
XFILLER_88_654 VGND VGND VPWR VPWR sky130_fd_sc_hd__decap_3
XFILLER_88_687 VGND VGND VPWR VPWR sky130_fd_sc_hd__decap_3
XFILLER_48_529 VGND VGND VPWR VPWR sky130_fd_sc_hd__decap_3
XFILLER_57_57 VGND VGND VPWR VPWR sky130_fd_sc_hd__decap_3
XFILLER_75_337 VGND VGND VPWR VPWR sky130_fd_sc_hd__decap_3
XFILLER_87_175 VGND VGND VPWR VPWR sky130_fd_sc_hd__decap_3
XFILLER_113_41 VGND VGND VPWR VPWR sky130_fd_sc_hd__decap_3
XFILLER_113_63 VGND VGND VPWR VPWR sky130_fd_sc_hd__decap_3
XFILLER_28_253 VGND VGND VPWR VPWR sky130_fd_sc_hd__decap_3
XFILLER_28_264 VGND VGND VPWR VPWR sky130_fd_sc_hd__decap_3
XFILLER_44_713 VGND VGND VPWR VPWR sky130_fd_sc_hd__fill_1
XFILLER_90_318 VGND VGND VPWR VPWR sky130_fd_sc_hd__fill_2
XFILLER_113_96 VGND VGND VPWR VPWR sky130_fd_sc_hd__decap_3
XFILLER_16_448 VGND VGND VPWR VPWR sky130_fd_sc_hd__decap_3
XFILLER_43_223 VGND VGND VPWR VPWR sky130_fd_sc_hd__fill_1
XFILLER_43_256 VGND VGND VPWR VPWR sky130_fd_sc_hd__decap_3
XFILLER_73_89 VGND VGND VPWR VPWR sky130_fd_sc_hd__fill_2
XTAP_TAPCELL_ROW_104_1552 VGND VPWR sky130_fd_sc_hd__tapvpwrvgnd_1
XFILLER_12_610 VGND VGND VPWR VPWR sky130_fd_sc_hd__decap_3
XFILLER_24_470 VGND VGND VPWR VPWR sky130_fd_sc_hd__decap_3
XFILLER_43_278 VGND VGND VPWR VPWR sky130_fd_sc_hd__fill_2
XFILLER_71_598 VGND VGND VPWR VPWR sky130_fd_sc_hd__decap_3
XTAP_TAPCELL_ROW_104_1563 VGND VPWR sky130_fd_sc_hd__tapvpwrvgnd_1
XFILLER_12_643 VGND VGND VPWR VPWR sky130_fd_sc_hd__fill_1
XFILLER_12_654 VGND VGND VPWR VPWR sky130_fd_sc_hd__decap_3
XFILLER_24_492 VGND VGND VPWR VPWR sky130_fd_sc_hd__decap_3
XFILLER_11_164 VGND VGND VPWR VPWR sky130_fd_sc_hd__decap_3
XFILLER_12_687 VGND VGND VPWR VPWR sky130_fd_sc_hd__decap_3
XFILLER_7_113 VGND VGND VPWR VPWR sky130_fd_sc_hd__decap_3
XFILLER_8_625 VGND VGND VPWR VPWR sky130_fd_sc_hd__decap_3
XFILLER_11_186 VGND VGND VPWR VPWR sky130_fd_sc_hd__fill_2
XFILLER_7_135 VGND VGND VPWR VPWR sky130_fd_sc_hd__decap_3
XFILLER_8_669 VGND VGND VPWR VPWR sky130_fd_sc_hd__decap_3
XFILLER_22_71 VGND VGND VPWR VPWR sky130_fd_sc_hd__decap_3
XFILLER_98_20 VGND VGND VPWR VPWR sky130_fd_sc_hd__decap_3
XFILLER_3_352 VGND VGND VPWR VPWR sky130_fd_sc_hd__decap_3
XFILLER_112_239 VGND VGND VPWR VPWR sky130_fd_sc_hd__decap_3
XFILLER_3_385 VGND VGND VPWR VPWR sky130_fd_sc_hd__fill_2
XFILLER_3_396 VGND VGND VPWR VPWR sky130_fd_sc_hd__fill_1
XFILLER_79_632 VGND VGND VPWR VPWR sky130_fd_sc_hd__decap_3
XTAP_TAPCELL_ROW_115_1692 VGND VPWR sky130_fd_sc_hd__tapvpwrvgnd_1
XFILLER_79_665 VGND VGND VPWR VPWR sky130_fd_sc_hd__decap_3
XFILLER_79_676 VGND VGND VPWR VPWR sky130_fd_sc_hd__decap_3
XFILLER_39_529 VGND VGND VPWR VPWR sky130_fd_sc_hd__decap_3
XFILLER_66_315 VGND VGND VPWR VPWR sky130_fd_sc_hd__decap_3
XFILLER_78_175 VGND VGND VPWR VPWR sky130_fd_sc_hd__decap_3
XFILLER_94_613 VGND VGND VPWR VPWR sky130_fd_sc_hd__decap_3
XFILLER_19_220 VGND VGND VPWR VPWR sky130_fd_sc_hd__decap_3
XFILLER_19_231 VGND VGND VPWR VPWR sky130_fd_sc_hd__decap_3
XFILLER_66_337 VGND VGND VPWR VPWR sky130_fd_sc_hd__fill_1
XFILLER_66_359 VGND VGND VPWR VPWR sky130_fd_sc_hd__decap_3
XFILLER_93_134 VGND VGND VPWR VPWR sky130_fd_sc_hd__decap_3
XFILLER_94_657 VGND VGND VPWR VPWR sky130_fd_sc_hd__decap_3
XFILLER_19_253 VGND VGND VPWR VPWR sky130_fd_sc_hd__decap_3
XTAP_TAPCELL_ROW_37_719 VGND VPWR sky130_fd_sc_hd__tapvpwrvgnd_1
XFILLER_34_223 VGND VGND VPWR VPWR sky130_fd_sc_hd__decap_3
XFILLER_47_595 VGND VGND VPWR VPWR sky130_fd_sc_hd__decap_3
XFILLER_34_256 VGND VGND VPWR VPWR sky130_fd_sc_hd__decap_3
XFILLER_62_554 VGND VGND VPWR VPWR sky130_fd_sc_hd__decap_3
XFILLER_34_289 VGND VGND VPWR VPWR sky130_fd_sc_hd__fill_2
XTAP_TAPCELL_ROW_66_1079 VGND VPWR sky130_fd_sc_hd__tapvpwrvgnd_1
XTAP_TAPCELL_ROW_17_476 VGND VPWR sky130_fd_sc_hd__tapvpwrvgnd_1
XTAP_TAPCELL_ROW_17_465 VGND VPWR sky130_fd_sc_hd__tapvpwrvgnd_1
XFILLER_15_492 VGND VGND VPWR VPWR sky130_fd_sc_hd__decap_3
X_4701_ _6989_/Q _6990_/Q _5044_/A VGND VGND VPWR VPWR _5026_/A sky130_fd_sc_hd__and3_2
XFILLER_30_473 VGND VGND VPWR VPWR sky130_fd_sc_hd__decap_3
X_4632_ _4626_/X _4274_/Y _4631_/X VGND VGND VPWR VPWR _4916_/B sky130_fd_sc_hd__a21oi_2
XFILLER_30_495 VGND VGND VPWR VPWR sky130_fd_sc_hd__decap_3
XFILLER_8_73 VGND VGND VPWR VPWR sky130_fd_sc_hd__decap_3
XFILLER_116_501 VGND VGND VPWR VPWR sky130_fd_sc_hd__decap_3
XFILLER_118_19 VGND VGND VPWR VPWR sky130_fd_sc_hd__decap_3
X_7351_ _7354_/CLK _7351_/D _6631_/Y VGND VGND VPWR VPWR _7351_/Q sky130_fd_sc_hd__dfrtp_2
X_4563_ _4563_/A _4563_/B VGND VGND VPWR VPWR _7299_/D sky130_fd_sc_hd__and2_2
XFILLER_116_556 VGND VGND VPWR VPWR sky130_fd_sc_hd__decap_3
XFILLER_7_691 VGND VGND VPWR VPWR sky130_fd_sc_hd__decap_3
X_7282_ _7313_/CLK _7282_/D _6562_/Y VGND VGND VPWR VPWR _7282_/Q sky130_fd_sc_hd__dfrtp_2
X_6302_ _6554_/A VGND VGND VPWR VPWR _6302_/Y sky130_fd_sc_hd__inv_2
XFILLER_104_707 VGND VGND VPWR VPWR sky130_fd_sc_hd__decap_3
XFILLER_116_589 VGND VGND VPWR VPWR sky130_fd_sc_hd__decap_3
XFILLER_89_418 VGND VGND VPWR VPWR sky130_fd_sc_hd__decap_3
XFILLER_103_217 VGND VGND VPWR VPWR sky130_fd_sc_hd__decap_3
XFILLER_97_440 VGND VGND VPWR VPWR sky130_fd_sc_hd__decap_3
XFILLER_97_462 VGND VGND VPWR VPWR sky130_fd_sc_hd__decap_3
X_3376_ _3376_/A _3376_/B VGND VGND VPWR VPWR _3376_/Y sky130_fd_sc_hd__nor2_2
XFILLER_111_250 VGND VGND VPWR VPWR sky130_fd_sc_hd__decap_3
XFILLER_69_175 VGND VGND VPWR VPWR sky130_fd_sc_hd__decap_3
XFILLER_84_112 VGND VGND VPWR VPWR sky130_fd_sc_hd__decap_3
XFILLER_85_635 VGND VGND VPWR VPWR sky130_fd_sc_hd__decap_3
Xhold1303 _7403_/Q VGND VGND VPWR VPWR _3693_/A0 sky130_fd_sc_hd__dlygate4sd3_1
Xhold1314 _7156_/Q VGND VGND VPWR VPWR _5350_/A0 sky130_fd_sc_hd__dlygate4sd3_1
X_5115_ _5101_/A _4292_/C _5113_/Y _5020_/A _5114_/Y VGND VGND VPWR VPWR _5115_/X
+ sky130_fd_sc_hd__o221a_2
XTAP_TAPCELL_ROW_90_1386 VGND VPWR sky130_fd_sc_hd__tapvpwrvgnd_1
XFILLER_57_337 VGND VGND VPWR VPWR sky130_fd_sc_hd__decap_3
XFILLER_85_668 VGND VGND VPWR VPWR sky130_fd_sc_hd__decap_3
X_5046_ _5101_/B VGND VGND VPWR VPWR _5100_/A sky130_fd_sc_hd__inv_2
XFILLER_26_713 VGND VGND VPWR VPWR sky130_fd_sc_hd__fill_1
XFILLER_84_167 VGND VGND VPWR VPWR sky130_fd_sc_hd__decap_3
XFILLER_85_679 VGND VGND VPWR VPWR sky130_fd_sc_hd__decap_3
XFILLER_25_212 VGND VGND VPWR VPWR sky130_fd_sc_hd__decap_3
XFILLER_38_595 VGND VGND VPWR VPWR sky130_fd_sc_hd__decap_3
XFILLER_65_370 VGND VGND VPWR VPWR sky130_fd_sc_hd__fill_2
X_6997_ _7371_/CLK _6997_/D _6277_/Y VGND VGND VPWR VPWR _6997_/Q sky130_fd_sc_hd__dfrtp_2
XFILLER_40_215 VGND VGND VPWR VPWR sky130_fd_sc_hd__decap_3
XFILLER_21_440 VGND VGND VPWR VPWR sky130_fd_sc_hd__decap_3
XFILLER_119_361 VGND VGND VPWR VPWR sky130_fd_sc_hd__decap_3
XFILLER_5_606 VGND VGND VPWR VPWR sky130_fd_sc_hd__decap_3
XFILLER_5_617 VGND VGND VPWR VPWR sky130_fd_sc_hd__decap_3
XFILLER_107_545 VGND VGND VPWR VPWR sky130_fd_sc_hd__decap_3
XFILLER_107_578 VGND VGND VPWR VPWR sky130_fd_sc_hd__fill_2
XFILLER_107_589 VGND VGND VPWR VPWR sky130_fd_sc_hd__decap_3
XFILLER_108_41 VGND VGND VPWR VPWR sky130_fd_sc_hd__decap_3
XFILLER_108_74 VGND VGND VPWR VPWR sky130_fd_sc_hd__decap_3
XFILLER_108_96 VGND VGND VPWR VPWR sky130_fd_sc_hd__decap_3
XFILLER_0_333 VGND VGND VPWR VPWR sky130_fd_sc_hd__decap_3
XFILLER_76_624 VGND VGND VPWR VPWR sky130_fd_sc_hd__decap_3
XFILLER_88_495 VGND VGND VPWR VPWR sky130_fd_sc_hd__decap_3
XFILLER_102_283 VGND VGND VPWR VPWR sky130_fd_sc_hd__decap_3
XFILLER_75_123 VGND VGND VPWR VPWR sky130_fd_sc_hd__decap_3
XFILLER_76_657 VGND VGND VPWR VPWR sky130_fd_sc_hd__decap_3
XFILLER_29_573 VGND VGND VPWR VPWR sky130_fd_sc_hd__decap_3
XFILLER_63_307 VGND VGND VPWR VPWR sky130_fd_sc_hd__decap_3
XFILLER_75_156 VGND VGND VPWR VPWR sky130_fd_sc_hd__decap_3
XFILLER_75_178 VGND VGND VPWR VPWR sky130_fd_sc_hd__decap_3
XFILLER_56_370 VGND VGND VPWR VPWR sky130_fd_sc_hd__decap_3
XFILLER_84_690 VGND VGND VPWR VPWR sky130_fd_sc_hd__decap_3
XFILLER_84_88 VGND VGND VPWR VPWR sky130_fd_sc_hd__decap_3
XFILLER_90_115 VGND VGND VPWR VPWR sky130_fd_sc_hd__decap_3
XFILLER_91_638 VGND VGND VPWR VPWR sky130_fd_sc_hd__decap_3
Xplace318 _4907_/Y VGND VGND VPWR VPWR _5657_/B sky130_fd_sc_hd__buf_2
XFILLER_16_256 VGND VGND VPWR VPWR sky130_fd_sc_hd__decap_3
XFILLER_17_60 VGND VGND VPWR VPWR sky130_fd_sc_hd__decap_3
XFILLER_44_543 VGND VGND VPWR VPWR sky130_fd_sc_hd__fill_1
Xplace329 _3665_/X VGND VGND VPWR VPWR _3850_/B1 sky130_fd_sc_hd__buf_2
XFILLER_16_289 VGND VGND VPWR VPWR sky130_fd_sc_hd__fill_1
XFILLER_17_93 VGND VGND VPWR VPWR sky130_fd_sc_hd__fill_1
XFILLER_44_598 VGND VGND VPWR VPWR sky130_fd_sc_hd__decap_3
XFILLER_31_237 VGND VGND VPWR VPWR sky130_fd_sc_hd__decap_3
XTAP_TAPCELL_ROW_14_435 VGND VPWR sky130_fd_sc_hd__tapvpwrvgnd_1
XFILLER_12_473 VGND VGND VPWR VPWR sky130_fd_sc_hd__decap_3
XTAP_TAPCELL_ROW_42_788 VGND VPWR sky130_fd_sc_hd__tapvpwrvgnd_1
XTAP_TAPCELL_ROW_42_777 VGND VPWR sky130_fd_sc_hd__tapvpwrvgnd_1
XFILLER_12_495 VGND VGND VPWR VPWR sky130_fd_sc_hd__decap_3
XFILLER_8_466 VGND VGND VPWR VPWR sky130_fd_sc_hd__decap_3
XFILLER_8_477 VGND VGND VPWR VPWR sky130_fd_sc_hd__decap_3
XTAP_TAPCELL_ROW_117_1721 VGND VPWR sky130_fd_sc_hd__tapvpwrvgnd_1
XFILLER_98_204 VGND VGND VPWR VPWR sky130_fd_sc_hd__decap_3
XFILLER_4_672 VGND VGND VPWR VPWR sky130_fd_sc_hd__decap_3
XFILLER_98_259 VGND VGND VPWR VPWR sky130_fd_sc_hd__fill_1
XFILLER_100_209 VGND VGND VPWR VPWR sky130_fd_sc_hd__fill_2
XFILLER_39_326 VGND VGND VPWR VPWR sky130_fd_sc_hd__fill_2
XFILLER_67_635 VGND VGND VPWR VPWR sky130_fd_sc_hd__decap_3
XFILLER_94_410 VGND VGND VPWR VPWR sky130_fd_sc_hd__fill_1
XFILLER_39_348 VGND VGND VPWR VPWR sky130_fd_sc_hd__decap_3
XFILLER_67_668 VGND VGND VPWR VPWR sky130_fd_sc_hd__decap_3
XFILLER_94_421 VGND VGND VPWR VPWR sky130_fd_sc_hd__decap_3
XFILLER_94_443 VGND VGND VPWR VPWR sky130_fd_sc_hd__decap_3
XFILLER_54_307 VGND VGND VPWR VPWR sky130_fd_sc_hd__fill_1
XFILLER_54_318 VGND VGND VPWR VPWR sky130_fd_sc_hd__decap_3
XFILLER_66_167 VGND VGND VPWR VPWR sky130_fd_sc_hd__fill_2
XFILLER_67_679 VGND VGND VPWR VPWR sky130_fd_sc_hd__decap_3
XFILLER_82_616 VGND VGND VPWR VPWR sky130_fd_sc_hd__decap_3
XTAP_TAPCELL_ROW_68_1108 VGND VPWR sky130_fd_sc_hd__tapvpwrvgnd_1
XFILLER_47_370 VGND VGND VPWR VPWR sky130_fd_sc_hd__fill_1
XFILLER_81_137 VGND VGND VPWR VPWR sky130_fd_sc_hd__decap_3
X_6920_ _7189_/CLK _6920_/D VGND VGND VPWR VPWR _6920_/Q sky130_fd_sc_hd__dfxtp_2
XFILLER_90_660 VGND VGND VPWR VPWR sky130_fd_sc_hd__decap_3
X_6851_ _7189_/CLK _6851_/D VGND VGND VPWR VPWR _6851_/Q sky130_fd_sc_hd__dfxtp_2
XFILLER_35_576 VGND VGND VPWR VPWR sky130_fd_sc_hd__decap_3
XFILLER_50_513 VGND VGND VPWR VPWR sky130_fd_sc_hd__decap_3
XFILLER_62_362 VGND VGND VPWR VPWR sky130_fd_sc_hd__fill_2
XFILLER_90_693 VGND VGND VPWR VPWR sky130_fd_sc_hd__decap_3
XFILLER_22_248 VGND VGND VPWR VPWR sky130_fd_sc_hd__decap_3
XFILLER_22_259 VGND VGND VPWR VPWR sky130_fd_sc_hd__decap_3
X_6782_ _6922_/CLK _6782_/D VGND VGND VPWR VPWR _6782_/Q sky130_fd_sc_hd__dfxtp_2
X_3994_ _7345_/Q _3993_/X _3994_/S VGND VGND VPWR VPWR _7345_/D sky130_fd_sc_hd__mux2_2
X_5733_ _7372_/Q _5733_/A1 _5735_/S VGND VGND VPWR VPWR _6716_/D sky130_fd_sc_hd__mux2_2
XFILLER_30_281 VGND VGND VPWR VPWR sky130_fd_sc_hd__decap_3
X_5664_ _5664_/A _5664_/B _5664_/C _5664_/D VGND VGND VPWR VPWR _5665_/D sky130_fd_sc_hd__and4_2
XFILLER_108_309 VGND VGND VPWR VPWR sky130_fd_sc_hd__fill_1
XFILLER_30_292 VGND VGND VPWR VPWR sky130_fd_sc_hd__decap_3
X_7403_ _7403_/CLK _7403_/D _6683_/Y VGND VGND VPWR VPWR _7403_/Q sky130_fd_sc_hd__dfrtp_2
X_5595_ _5595_/A _5595_/B VGND VGND VPWR VPWR _7030_/D sky130_fd_sc_hd__or2_2
X_4615_ _4612_/A _4612_/B _3610_/A VGND VGND VPWR VPWR _4615_/Y sky130_fd_sc_hd__a21oi_2
XTAP_TAPCELL_ROW_79_1248 VGND VPWR sky130_fd_sc_hd__tapvpwrvgnd_1
XFILLER_116_331 VGND VGND VPWR VPWR sky130_fd_sc_hd__decap_3
X_7334_ _7370_/CLK _7334_/D _6614_/Y VGND VGND VPWR VPWR _7334_/Q sky130_fd_sc_hd__dfrtp_2
X_4546_ _4546_/A _4563_/B VGND VGND VPWR VPWR _7307_/D sky130_fd_sc_hd__and2_2
XTAP_TAPCELL_ROW_92_1404 VGND VPWR sky130_fd_sc_hd__tapvpwrvgnd_1
XFILLER_116_375 VGND VGND VPWR VPWR sky130_fd_sc_hd__decap_3
XFILLER_116_397 VGND VGND VPWR VPWR sky130_fd_sc_hd__fill_2
X_7265_ _7362_/CLK _7265_/D _6545_/Y VGND VGND VPWR VPWR _7265_/Q sky130_fd_sc_hd__dfrtp_2
XFILLER_89_248 VGND VGND VPWR VPWR sky130_fd_sc_hd__decap_3
X_7196_ _7358_/CLK _7196_/D _6476_/Y VGND VGND VPWR VPWR _7196_/Q sky130_fd_sc_hd__dfrtp_2
XFILLER_100_710 VGND VGND VPWR VPWR sky130_fd_sc_hd__decap_3
XFILLER_58_613 VGND VGND VPWR VPWR sky130_fd_sc_hd__decap_3
Xhold1100 _7193_/Q VGND VGND VPWR VPWR _5274_/A0 sky130_fd_sc_hd__dlygate4sd3_1
X_3359_ _6983_/Q _5130_/A VGND VGND VPWR VPWR _3376_/A sky130_fd_sc_hd__or2_2
XFILLER_112_592 VGND VGND VPWR VPWR sky130_fd_sc_hd__decap_3
XFILLER_58_657 VGND VGND VPWR VPWR sky130_fd_sc_hd__decap_3
XFILLER_85_432 VGND VGND VPWR VPWR sky130_fd_sc_hd__decap_3
XFILLER_97_281 VGND VGND VPWR VPWR sky130_fd_sc_hd__decap_3
Xhold1111 _7244_/Q VGND VGND VPWR VPWR _5167_/A sky130_fd_sc_hd__dlygate4sd3_1
Xhold1122 _7206_/Q VGND VGND VPWR VPWR _5247_/A0 sky130_fd_sc_hd__dlygate4sd3_1
Xhold1133 _7391_/Q VGND VGND VPWR VPWR _3814_/A1 sky130_fd_sc_hd__dlygate4sd3_1
Xhold1144 _7254_/Q VGND VGND VPWR VPWR _5122_/A0 sky130_fd_sc_hd__dlygate4sd3_1
Xhold1155 _7245_/Q VGND VGND VPWR VPWR _5165_/A sky130_fd_sc_hd__dlygate4sd3_1
Xhold1166 _7323_/Q VGND VGND VPWR VPWR _4513_/A0 sky130_fd_sc_hd__dlygate4sd3_1
XFILLER_26_510 VGND VGND VPWR VPWR sky130_fd_sc_hd__decap_3
XFILLER_66_690 VGND VGND VPWR VPWR sky130_fd_sc_hd__decap_3
XFILLER_72_115 VGND VGND VPWR VPWR sky130_fd_sc_hd__decap_3
XFILLER_72_126 VGND VGND VPWR VPWR sky130_fd_sc_hd__decap_3
XFILLER_73_638 VGND VGND VPWR VPWR sky130_fd_sc_hd__decap_3
Xhold1177 _7217_/Q VGND VGND VPWR VPWR _5223_/A sky130_fd_sc_hd__dlygate4sd3_1
Xhold1188 _7219_/Q VGND VGND VPWR VPWR _5219_/A sky130_fd_sc_hd__dlygate4sd3_1
Xhold1199 _7227_/Q VGND VGND VPWR VPWR _5203_/A sky130_fd_sc_hd__dlygate4sd3_1
XFILLER_26_598 VGND VGND VPWR VPWR sky130_fd_sc_hd__decap_3
XFILLER_41_502 VGND VGND VPWR VPWR sky130_fd_sc_hd__fill_2
XFILLER_53_384 VGND VGND VPWR VPWR sky130_fd_sc_hd__decap_3
XFILLER_81_671 VGND VGND VPWR VPWR sky130_fd_sc_hd__fill_1
XFILLER_81_682 VGND VGND VPWR VPWR sky130_fd_sc_hd__decap_3
XFILLER_110_20 VGND VGND VPWR VPWR sky130_fd_sc_hd__decap_3
XFILLER_110_53 VGND VGND VPWR VPWR sky130_fd_sc_hd__decap_3
XFILLER_41_546 VGND VGND VPWR VPWR sky130_fd_sc_hd__fill_1
XFILLER_80_192 VGND VGND VPWR VPWR sky130_fd_sc_hd__decap_3
XTAP_TAPCELL_ROW_101_1522 VGND VPWR sky130_fd_sc_hd__tapvpwrvgnd_1
XFILLER_9_208 VGND VGND VPWR VPWR sky130_fd_sc_hd__decap_3
XFILLER_110_97 VGND VGND VPWR VPWR sky130_fd_sc_hd__decap_3
XFILLER_21_281 VGND VGND VPWR VPWR sky130_fd_sc_hd__decap_3
XFILLER_119_51 VGND VGND VPWR VPWR sky130_fd_sc_hd__decap_3
XFILLER_107_364 VGND VGND VPWR VPWR sky130_fd_sc_hd__decap_3
XFILLER_1_620 VGND VGND VPWR VPWR sky130_fd_sc_hd__decap_3
XFILLER_1_653 VGND VGND VPWR VPWR sky130_fd_sc_hd__decap_3
XFILLER_79_99 VGND VGND VPWR VPWR sky130_fd_sc_hd__decap_3
XTAP_TAPCELL_ROW_112_1662 VGND VPWR sky130_fd_sc_hd__tapvpwrvgnd_1
XFILLER_0_141 VGND VGND VPWR VPWR sky130_fd_sc_hd__decap_3
XFILLER_0_163 VGND VGND VPWR VPWR sky130_fd_sc_hd__decap_3
XFILLER_49_635 VGND VGND VPWR VPWR sky130_fd_sc_hd__decap_3
XFILLER_76_432 VGND VGND VPWR VPWR sky130_fd_sc_hd__decap_3
XFILLER_88_292 VGND VGND VPWR VPWR sky130_fd_sc_hd__decap_3
XFILLER_36_318 VGND VGND VPWR VPWR sky130_fd_sc_hd__decap_3
XFILLER_49_668 VGND VGND VPWR VPWR sky130_fd_sc_hd__decap_3
XFILLER_49_679 VGND VGND VPWR VPWR sky130_fd_sc_hd__decap_3
XFILLER_64_616 VGND VGND VPWR VPWR sky130_fd_sc_hd__decap_3
XFILLER_76_465 VGND VGND VPWR VPWR sky130_fd_sc_hd__decap_3
XFILLER_95_98 VGND VGND VPWR VPWR sky130_fd_sc_hd__decap_3
XFILLER_28_81 VGND VGND VPWR VPWR sky130_fd_sc_hd__decap_3
XFILLER_29_370 VGND VGND VPWR VPWR sky130_fd_sc_hd__decap_3
XFILLER_48_178 VGND VGND VPWR VPWR sky130_fd_sc_hd__decap_3
XFILLER_76_498 VGND VGND VPWR VPWR sky130_fd_sc_hd__decap_3
XFILLER_91_424 VGND VGND VPWR VPWR sky130_fd_sc_hd__decap_3
XTAP_TAPCELL_ROW_47_847 VGND VPWR sky130_fd_sc_hd__tapvpwrvgnd_1
XFILLER_44_340 VGND VGND VPWR VPWR sky130_fd_sc_hd__decap_3
XFILLER_17_587 VGND VGND VPWR VPWR sky130_fd_sc_hd__decap_3
XFILLER_72_660 VGND VGND VPWR VPWR sky130_fd_sc_hd__decap_3
XFILLER_72_693 VGND VGND VPWR VPWR sky130_fd_sc_hd__decap_3
XFILLER_71_181 VGND VGND VPWR VPWR sky130_fd_sc_hd__decap_3
XTAP_TAPCELL_ROW_63_1049 VGND VPWR sky130_fd_sc_hd__tapvpwrvgnd_1
XTAP_TAPCELL_ROW_27_593 VGND VPWR sky130_fd_sc_hd__tapvpwrvgnd_1
XFILLER_32_579 VGND VGND VPWR VPWR sky130_fd_sc_hd__decap_3
XFILLER_44_91 VGND VGND VPWR VPWR sky130_fd_sc_hd__decap_3
XFILLER_118_607 VGND VGND VPWR VPWR sky130_fd_sc_hd__decap_3
XFILLER_8_296 VGND VGND VPWR VPWR sky130_fd_sc_hd__decap_3
X_4400_ _7178_/Q _4459_/C1 _4428_/B1 _7146_/Q _4399_/X VGND VGND VPWR VPWR _4400_/X
+ sky130_fd_sc_hd__a221o_2
XFILLER_113_312 VGND VGND VPWR VPWR sky130_fd_sc_hd__decap_3
XFILLER_5_52 VGND VGND VPWR VPWR sky130_fd_sc_hd__decap_3
X_4331_ _7223_/Q _3318_/B _4534_/S _7036_/Q VGND VGND VPWR VPWR _4331_/X sky130_fd_sc_hd__a22o_2
XFILLER_99_535 VGND VGND VPWR VPWR sky130_fd_sc_hd__decap_3
XFILLER_113_334 VGND VGND VPWR VPWR sky130_fd_sc_hd__fill_2
XFILLER_4_480 VGND VGND VPWR VPWR sky130_fd_sc_hd__decap_3
XFILLER_5_74 VGND VGND VPWR VPWR sky130_fd_sc_hd__fill_1
X_7050_ _7400_/CLK _7050_/D _6330_/Y VGND VGND VPWR VPWR _7050_/Q sky130_fd_sc_hd__dfrtp_2
X_4262_ _7230_/Q _4421_/A2 _4419_/A2 _7294_/Q VGND VGND VPWR VPWR _4262_/X sky130_fd_sc_hd__a22o_2
XTAP_TAPCELL_ROW_74_1189 VGND VPWR sky130_fd_sc_hd__tapvpwrvgnd_1
XTAP_TAPCELL_ROW_74_1178 VGND VPWR sky130_fd_sc_hd__tapvpwrvgnd_1
XFILLER_101_518 VGND VGND VPWR VPWR sky130_fd_sc_hd__decap_3
XFILLER_113_367 VGND VGND VPWR VPWR sky130_fd_sc_hd__fill_2
XFILLER_86_218 VGND VGND VPWR VPWR sky130_fd_sc_hd__decap_3
XFILLER_67_432 VGND VGND VPWR VPWR sky130_fd_sc_hd__decap_3
XFILLER_79_281 VGND VGND VPWR VPWR sky130_fd_sc_hd__decap_3
X_4193_ _7359_/Q _4416_/A2 _4417_/B1 _7103_/Q VGND VGND VPWR VPWR _4193_/X sky130_fd_sc_hd__a22o_2
XFILLER_39_156 VGND VGND VPWR VPWR sky130_fd_sc_hd__fill_2
XFILLER_27_318 VGND VGND VPWR VPWR sky130_fd_sc_hd__decap_3
XFILLER_39_178 VGND VGND VPWR VPWR sky130_fd_sc_hd__fill_1
XFILLER_48_690 VGND VGND VPWR VPWR sky130_fd_sc_hd__decap_3
XFILLER_54_126 VGND VGND VPWR VPWR sky130_fd_sc_hd__decap_3
XFILLER_55_638 VGND VGND VPWR VPWR sky130_fd_sc_hd__decap_3
XFILLER_94_284 VGND VGND VPWR VPWR sky130_fd_sc_hd__decap_3
XFILLER_54_159 VGND VGND VPWR VPWR sky130_fd_sc_hd__decap_3
XFILLER_70_619 VGND VGND VPWR VPWR sky130_fd_sc_hd__decap_3
X_6903_ clkload8/A _6903_/D VGND VGND VPWR VPWR _6903_/Q sky130_fd_sc_hd__dfxtp_2
XFILLER_23_524 VGND VGND VPWR VPWR sky130_fd_sc_hd__decap_3
XFILLER_63_671 VGND VGND VPWR VPWR sky130_fd_sc_hd__fill_1
XFILLER_63_682 VGND VGND VPWR VPWR sky130_fd_sc_hd__decap_3
X_6834_ _7189_/CLK _6834_/D VGND VGND VPWR VPWR _6834_/Q sky130_fd_sc_hd__dfxtp_2
XFILLER_50_365 VGND VGND VPWR VPWR sky130_fd_sc_hd__decap_3
X_6765_ _6906_/CLK _6765_/D VGND VGND VPWR VPWR _6765_/Q sky130_fd_sc_hd__dfxtp_2
X_3977_ _7352_/Q _4519_/A1 _3987_/S VGND VGND VPWR VPWR _7352_/D sky130_fd_sc_hd__mux2_2
XFILLER_109_629 VGND VGND VPWR VPWR sky130_fd_sc_hd__decap_3
X_6696_ _6922_/CLK _6696_/D VGND VGND VPWR VPWR _6696_/Q sky130_fd_sc_hd__dfxtp_2
XFILLER_108_139 VGND VGND VPWR VPWR sky130_fd_sc_hd__fill_1
X_5647_ _5647_/A _5647_/B VGND VGND VPWR VPWR _5647_/Y sky130_fd_sc_hd__nand2_2
XFILLER_117_662 VGND VGND VPWR VPWR sky130_fd_sc_hd__decap_3
XFILLER_116_150 VGND VGND VPWR VPWR sky130_fd_sc_hd__fill_1
XFILLER_117_673 VGND VGND VPWR VPWR sky130_fd_sc_hd__decap_3
X_7317_ _7345_/CLK _7317_/D _6597_/Y VGND VGND VPWR VPWR _7317_/Q sky130_fd_sc_hd__dfrtp_2
XFILLER_104_345 VGND VGND VPWR VPWR sky130_fd_sc_hd__decap_3
XFILLER_116_183 VGND VGND VPWR VPWR sky130_fd_sc_hd__decap_3
XFILLER_49_14 VGND VGND VPWR VPWR sky130_fd_sc_hd__decap_3
X_7248_ _7387_/CLK _7248_/D _6528_/Y VGND VGND VPWR VPWR _7248_/Q sky130_fd_sc_hd__dfrtp_2
XFILLER_104_389 VGND VGND VPWR VPWR sky130_fd_sc_hd__decap_3
XFILLER_77_207 VGND VGND VPWR VPWR sky130_fd_sc_hd__fill_2
XFILLER_58_421 VGND VGND VPWR VPWR sky130_fd_sc_hd__fill_1
X_7179_ _7371_/CLK _7179_/D _6459_/Y VGND VGND VPWR VPWR _7179_/Q sky130_fd_sc_hd__dfrtp_2
XFILLER_46_616 VGND VGND VPWR VPWR sky130_fd_sc_hd__decap_3
XFILLER_73_402 VGND VGND VPWR VPWR sky130_fd_sc_hd__fill_2
XFILLER_85_240 VGND VGND VPWR VPWR sky130_fd_sc_hd__decap_3
XFILLER_105_86 VGND VGND VPWR VPWR sky130_fd_sc_hd__decap_3
XFILLER_18_318 VGND VGND VPWR VPWR sky130_fd_sc_hd__decap_3
XFILLER_85_284 VGND VGND VPWR VPWR sky130_fd_sc_hd__decap_3
XFILLER_45_159 VGND VGND VPWR VPWR sky130_fd_sc_hd__fill_1
XFILLER_61_608 VGND VGND VPWR VPWR sky130_fd_sc_hd__decap_3
XTAP_TAPCELL_ROW_44_806 VGND VPWR sky130_fd_sc_hd__tapvpwrvgnd_1
XFILLER_54_660 VGND VGND VPWR VPWR sky130_fd_sc_hd__decap_3
XFILLER_14_524 VGND VGND VPWR VPWR sky130_fd_sc_hd__decap_3
XFILLER_54_693 VGND VGND VPWR VPWR sky130_fd_sc_hd__decap_3
XFILLER_14_579 VGND VGND VPWR VPWR sky130_fd_sc_hd__decap_3
XFILLER_41_343 VGND VGND VPWR VPWR sky130_fd_sc_hd__decap_3
XFILLER_81_78 VGND VGND VPWR VPWR sky130_fd_sc_hd__fill_1
XTAP_TAPCELL_ROW_24_563 VGND VPWR sky130_fd_sc_hd__tapvpwrvgnd_1
XTAP_TAPCELL_ROW_24_552 VGND VPWR sky130_fd_sc_hd__tapvpwrvgnd_1
XFILLER_81_89 VGND VGND VPWR VPWR sky130_fd_sc_hd__decap_3
XFILLER_6_701 VGND VGND VPWR VPWR sky130_fd_sc_hd__decap_3
XFILLER_5_200 VGND VGND VPWR VPWR sky130_fd_sc_hd__decap_3
XFILLER_108_640 VGND VGND VPWR VPWR sky130_fd_sc_hd__decap_3
XFILLER_108_651 VGND VGND VPWR VPWR sky130_fd_sc_hd__decap_3
XFILLER_107_161 VGND VGND VPWR VPWR sky130_fd_sc_hd__decap_3
XFILLER_107_172 VGND VGND VPWR VPWR sky130_fd_sc_hd__decap_3
XFILLER_108_684 VGND VGND VPWR VPWR sky130_fd_sc_hd__decap_3
XFILLER_30_60 VGND VGND VPWR VPWR sky130_fd_sc_hd__decap_3
XFILLER_30_82 VGND VGND VPWR VPWR sky130_fd_sc_hd__fill_2
XFILLER_110_315 VGND VGND VPWR VPWR sky130_fd_sc_hd__decap_3
XFILLER_96_516 VGND VGND VPWR VPWR sky130_fd_sc_hd__decap_3
XFILLER_1_472 VGND VGND VPWR VPWR sky130_fd_sc_hd__decap_3
XFILLER_49_410 VGND VGND VPWR VPWR sky130_fd_sc_hd__fill_2
XFILLER_110_359 VGND VGND VPWR VPWR sky130_fd_sc_hd__decap_3
XFILLER_37_605 VGND VGND VPWR VPWR sky130_fd_sc_hd__decap_3
XFILLER_49_454 VGND VGND VPWR VPWR sky130_fd_sc_hd__decap_3
XFILLER_76_240 VGND VGND VPWR VPWR sky130_fd_sc_hd__decap_3
XFILLER_36_104 VGND VGND VPWR VPWR sky130_fd_sc_hd__fill_1
XFILLER_37_638 VGND VGND VPWR VPWR sky130_fd_sc_hd__decap_3
XFILLER_49_498 VGND VGND VPWR VPWR sky130_fd_sc_hd__decap_3
XFILLER_76_295 VGND VGND VPWR VPWR sky130_fd_sc_hd__decap_3
XFILLER_17_340 VGND VGND VPWR VPWR sky130_fd_sc_hd__decap_3
XFILLER_36_137 VGND VGND VPWR VPWR sky130_fd_sc_hd__decap_3
XFILLER_91_221 VGND VGND VPWR VPWR sky130_fd_sc_hd__decap_3
XFILLER_91_254 VGND VGND VPWR VPWR sky130_fd_sc_hd__fill_2
XFILLER_17_362 VGND VGND VPWR VPWR sky130_fd_sc_hd__fill_2
XFILLER_45_671 VGND VGND VPWR VPWR sky130_fd_sc_hd__fill_1
XFILLER_45_682 VGND VGND VPWR VPWR sky130_fd_sc_hd__decap_3
XFILLER_52_619 VGND VGND VPWR VPWR sky130_fd_sc_hd__decap_3
XFILLER_32_321 VGND VGND VPWR VPWR sky130_fd_sc_hd__fill_1
XFILLER_32_332 VGND VGND VPWR VPWR sky130_fd_sc_hd__fill_1
XFILLER_44_181 VGND VGND VPWR VPWR sky130_fd_sc_hd__decap_3
X_3900_ _3898_/X _3899_/X _4770_/A1 VGND VGND VPWR VPWR _3900_/Y sky130_fd_sc_hd__o21ai_2
XFILLER_32_343 VGND VGND VPWR VPWR sky130_fd_sc_hd__decap_3
XFILLER_32_365 VGND VGND VPWR VPWR sky130_fd_sc_hd__decap_3
XFILLER_60_663 VGND VGND VPWR VPWR sky130_fd_sc_hd__decap_3
X_3831_ _3682_/A _3828_/X _3830_/X _3714_/X VGND VGND VPWR VPWR _3831_/X sky130_fd_sc_hd__a22o_2
XFILLER_20_527 VGND VGND VPWR VPWR sky130_fd_sc_hd__decap_3
XFILLER_32_376 VGND VGND VPWR VPWR sky130_fd_sc_hd__decap_3
XFILLER_60_696 VGND VGND VPWR VPWR sky130_fd_sc_hd__decap_3
X_6550_ _6550_/A VGND VGND VPWR VPWR _6550_/Y sky130_fd_sc_hd__inv_2
X_3762_ _3746_/C _3759_/X _3760_/X _4770_/A1 VGND VGND VPWR VPWR _3762_/X sky130_fd_sc_hd__o31a_2
XFILLER_9_561 VGND VGND VPWR VPWR sky130_fd_sc_hd__decap_3
X_6481_ _6676_/A VGND VGND VPWR VPWR _6481_/Y sky130_fd_sc_hd__inv_2
X_3693_ _3693_/A0 _3692_/X _4832_/A VGND VGND VPWR VPWR _7403_/D sky130_fd_sc_hd__mux2_2
XFILLER_9_594 VGND VGND VPWR VPWR sky130_fd_sc_hd__decap_3
XTAP_TAPCELL_ROW_76_1207 VGND VPWR sky130_fd_sc_hd__tapvpwrvgnd_1
XFILLER_114_610 VGND VGND VPWR VPWR sky130_fd_sc_hd__decap_3
XFILLER_113_131 VGND VGND VPWR VPWR sky130_fd_sc_hd__decap_3
XFILLER_114_643 VGND VGND VPWR VPWR sky130_fd_sc_hd__fill_1
XFILLER_114_654 VGND VGND VPWR VPWR sky130_fd_sc_hd__decap_3
X_7102_ _7360_/CLK _7102_/D _6382_/Y VGND VGND VPWR VPWR _7102_/Q sky130_fd_sc_hd__dfrtp_2
X_4314_ _4376_/A _4364_/A _4364_/B _4313_/D VGND VGND VPWR VPWR _4315_/B sky130_fd_sc_hd__o31ai_2
XFILLER_99_354 VGND VGND VPWR VPWR sky130_fd_sc_hd__decap_3
XFILLER_101_304 VGND VGND VPWR VPWR sky130_fd_sc_hd__decap_3
XFILLER_114_687 VGND VGND VPWR VPWR sky130_fd_sc_hd__decap_3
XFILLER_87_505 VGND VGND VPWR VPWR sky130_fd_sc_hd__decap_3
X_5294_ _5294_/A _5294_/B VGND VGND VPWR VPWR _5294_/Y sky130_fd_sc_hd__nor2_2
XFILLER_99_376 VGND VGND VPWR VPWR sky130_fd_sc_hd__fill_1
XFILLER_101_326 VGND VGND VPWR VPWR sky130_fd_sc_hd__decap_3
XFILLER_101_337 VGND VGND VPWR VPWR sky130_fd_sc_hd__decap_3
XFILLER_59_229 VGND VGND VPWR VPWR sky130_fd_sc_hd__decap_3
X_7033_ _7345_/CLK _7033_/D _6313_/Y VGND VGND VPWR VPWR _7033_/Q sky130_fd_sc_hd__dfrtp_2
X_4245_ _7357_/Q _4261_/A2 _4421_/B1 _7165_/Q _4244_/X VGND VGND VPWR VPWR _4248_/B
+ sky130_fd_sc_hd__a221o_2
XFILLER_28_616 VGND VGND VPWR VPWR sky130_fd_sc_hd__decap_3
XFILLER_83_700 VGND VGND VPWR VPWR sky130_fd_sc_hd__decap_3
X_4176_ _7168_/Q _3366_/X _4263_/A2 _7136_/Q VGND VGND VPWR VPWR _4176_/X sky130_fd_sc_hd__a22o_2
XFILLER_67_262 VGND VGND VPWR VPWR sky130_fd_sc_hd__decap_3
XFILLER_67_284 VGND VGND VPWR VPWR sky130_fd_sc_hd__decap_3
XFILLER_95_582 VGND VGND VPWR VPWR sky130_fd_sc_hd__decap_3
XFILLER_27_137 VGND VGND VPWR VPWR sky130_fd_sc_hd__decap_3
XFILLER_82_243 VGND VGND VPWR VPWR sky130_fd_sc_hd__decap_3
XTAP_TAPCELL_ROW_87_1347 VGND VPWR sky130_fd_sc_hd__tapvpwrvgnd_1
XFILLER_35_49 VGND VGND VPWR VPWR sky130_fd_sc_hd__decap_3
XFILLER_36_660 VGND VGND VPWR VPWR sky130_fd_sc_hd__decap_3
XFILLER_42_107 VGND VGND VPWR VPWR sky130_fd_sc_hd__fill_1
XFILLER_70_427 VGND VGND VPWR VPWR sky130_fd_sc_hd__decap_3
XFILLER_82_276 VGND VGND VPWR VPWR sky130_fd_sc_hd__decap_3
XFILLER_35_181 VGND VGND VPWR VPWR sky130_fd_sc_hd__decap_3
XFILLER_36_693 VGND VGND VPWR VPWR sky130_fd_sc_hd__decap_3
XFILLER_51_641 VGND VGND VPWR VPWR sky130_fd_sc_hd__decap_3
XFILLER_23_343 VGND VGND VPWR VPWR sky130_fd_sc_hd__fill_2
Xplace490 _3341_/A VGND VGND VPWR VPWR _5156_/S sky130_fd_sc_hd__buf_2
X_6817_ clkload5/A _6817_/D VGND VGND VPWR VPWR _6817_/Q sky130_fd_sc_hd__dfxtp_2
XFILLER_11_516 VGND VGND VPWR VPWR sky130_fd_sc_hd__fill_1
XFILLER_11_538 VGND VGND VPWR VPWR sky130_fd_sc_hd__decap_3
XFILLER_50_173 VGND VGND VPWR VPWR sky130_fd_sc_hd__decap_3
XFILLER_51_685 VGND VGND VPWR VPWR sky130_fd_sc_hd__decap_3
X_6748_ clkload6/A _6748_/D VGND VGND VPWR VPWR _6748_/Q sky130_fd_sc_hd__dfxtp_2
XTAP_TAPCELL_ROW_21_522 VGND VPWR sky130_fd_sc_hd__tapvpwrvgnd_1
X_6679_ _6683_/A VGND VGND VPWR VPWR _6679_/Y sky130_fd_sc_hd__inv_2
XTAP_TAPCELL_ROW_98_1487 VGND VPWR sky130_fd_sc_hd__tapvpwrvgnd_1
XFILLER_105_632 VGND VGND VPWR VPWR sky130_fd_sc_hd__decap_3
XFILLER_2_247 VGND VGND VPWR VPWR sky130_fd_sc_hd__decap_3
XFILLER_104_153 VGND VGND VPWR VPWR sky130_fd_sc_hd__decap_3
XFILLER_105_665 VGND VGND VPWR VPWR sky130_fd_sc_hd__decap_3
XFILLER_105_676 VGND VGND VPWR VPWR sky130_fd_sc_hd__decap_3
XFILLER_116_41 VGND VGND VPWR VPWR sky130_fd_sc_hd__decap_3
XFILLER_78_505 VGND VGND VPWR VPWR sky130_fd_sc_hd__decap_3
XFILLER_104_186 VGND VGND VPWR VPWR sky130_fd_sc_hd__decap_3
XFILLER_104_197 VGND VGND VPWR VPWR sky130_fd_sc_hd__decap_3
XFILLER_116_74 VGND VGND VPWR VPWR sky130_fd_sc_hd__decap_3
XFILLER_116_85 VGND VGND VPWR VPWR sky130_fd_sc_hd__decap_3
XFILLER_76_12 VGND VGND VPWR VPWR sky130_fd_sc_hd__decap_3
XFILLER_58_251 VGND VGND VPWR VPWR sky130_fd_sc_hd__fill_1
XFILLER_19_638 VGND VGND VPWR VPWR sky130_fd_sc_hd__decap_3
XFILLER_46_413 VGND VGND VPWR VPWR sky130_fd_sc_hd__decap_3
XFILLER_100_381 VGND VGND VPWR VPWR sky130_fd_sc_hd__decap_3
XFILLER_46_435 VGND VGND VPWR VPWR sky130_fd_sc_hd__decap_3
XFILLER_46_468 VGND VGND VPWR VPWR sky130_fd_sc_hd__decap_3
XFILLER_73_221 VGND VGND VPWR VPWR sky130_fd_sc_hd__decap_3
XTAP_TAPCELL_ROW_29_622 VGND VPWR sky130_fd_sc_hd__tapvpwrvgnd_1
XFILLER_27_671 VGND VGND VPWR VPWR sky130_fd_sc_hd__fill_1
XFILLER_34_619 VGND VGND VPWR VPWR sky130_fd_sc_hd__decap_3
XFILLER_73_265 VGND VGND VPWR VPWR sky130_fd_sc_hd__decap_3
XFILLER_73_287 VGND VGND VPWR VPWR sky130_fd_sc_hd__decap_3
XTAP_TAPCELL_ROW_57_975 VGND VPWR sky130_fd_sc_hd__tapvpwrvgnd_1
XFILLER_14_321 VGND VGND VPWR VPWR sky130_fd_sc_hd__decap_3
XFILLER_26_170 VGND VGND VPWR VPWR sky130_fd_sc_hd__decap_3
XFILLER_26_181 VGND VGND VPWR VPWR sky130_fd_sc_hd__decap_3
XFILLER_27_682 VGND VGND VPWR VPWR sky130_fd_sc_hd__decap_3
XFILLER_42_630 VGND VGND VPWR VPWR sky130_fd_sc_hd__decap_3
XFILLER_73_298 VGND VGND VPWR VPWR sky130_fd_sc_hd__decap_3
XFILLER_92_66 VGND VGND VPWR VPWR sky130_fd_sc_hd__decap_3
XFILLER_92_88 VGND VGND VPWR VPWR sky130_fd_sc_hd__decap_3
XTAP_TAPCELL_ROW_107_1594 VGND VPWR sky130_fd_sc_hd__tapvpwrvgnd_1
XFILLER_14_343 VGND VGND VPWR VPWR sky130_fd_sc_hd__decap_3
XFILLER_14_365 VGND VGND VPWR VPWR sky130_fd_sc_hd__fill_1
XFILLER_25_60 VGND VGND VPWR VPWR sky130_fd_sc_hd__fill_2
XFILLER_42_663 VGND VGND VPWR VPWR sky130_fd_sc_hd__decap_3
XFILLER_25_93 VGND VGND VPWR VPWR sky130_fd_sc_hd__fill_1
XFILLER_42_696 VGND VGND VPWR VPWR sky130_fd_sc_hd__decap_3
XTAP_TAPCELL_ROW_60_1008 VGND VPWR sky130_fd_sc_hd__tapvpwrvgnd_1
XFILLER_10_560 VGND VGND VPWR VPWR sky130_fd_sc_hd__decap_3
XFILLER_6_542 VGND VGND VPWR VPWR sky130_fd_sc_hd__decap_3
XFILLER_6_575 VGND VGND VPWR VPWR sky130_fd_sc_hd__decap_3
XFILLER_44_6 VGND VGND VPWR VPWR sky130_fd_sc_hd__decap_3
XFILLER_110_112 VGND VGND VPWR VPWR sky130_fd_sc_hd__decap_3
XFILLER_111_635 VGND VGND VPWR VPWR sky130_fd_sc_hd__decap_3
XTAP_TAPCELL_ROW_71_1148 VGND VPWR sky130_fd_sc_hd__tapvpwrvgnd_1
XFILLER_111_668 VGND VGND VPWR VPWR sky130_fd_sc_hd__decap_3
XFILLER_111_679 VGND VGND VPWR VPWR sky130_fd_sc_hd__decap_3
XFILLER_65_700 VGND VGND VPWR VPWR sky130_fd_sc_hd__decap_3
XFILLER_96_368 VGND VGND VPWR VPWR sky130_fd_sc_hd__decap_3
XPHY_EDGE_ROW_10_Right_10 VGND VGND VPWR VPWR sky130_fd_sc_hd__decap_3
XFILLER_110_189 VGND VGND VPWR VPWR sky130_fd_sc_hd__decap_3
XFILLER_49_284 VGND VGND VPWR VPWR sky130_fd_sc_hd__decap_3
XFILLER_64_210 VGND VGND VPWR VPWR sky130_fd_sc_hd__decap_3
XFILLER_37_435 VGND VGND VPWR VPWR sky130_fd_sc_hd__decap_3
XFILLER_64_243 VGND VGND VPWR VPWR sky130_fd_sc_hd__decap_3
XFILLER_92_530 VGND VGND VPWR VPWR sky130_fd_sc_hd__fill_2
XFILLER_18_660 VGND VGND VPWR VPWR sky130_fd_sc_hd__decap_3
XFILLER_17_181 VGND VGND VPWR VPWR sky130_fd_sc_hd__fill_2
XFILLER_18_693 VGND VGND VPWR VPWR sky130_fd_sc_hd__decap_3
XFILLER_24_118 VGND VGND VPWR VPWR sky130_fd_sc_hd__fill_2
XFILLER_24_129 VGND VGND VPWR VPWR sky130_fd_sc_hd__decap_3
XFILLER_64_298 VGND VGND VPWR VPWR sky130_fd_sc_hd__decap_3
Xclkbuf_leaf_44_clk clkbuf_leaf_1_clk/A VGND VGND VPWR VPWR clkload7/A sky130_fd_sc_hd__clkbuf_16
X_4932_ _4910_/A _4927_/X _4929_/Y _6996_/D _5666_/A VGND VGND VPWR VPWR _4932_/X
+ sky130_fd_sc_hd__a32o_2
XFILLER_33_641 VGND VGND VPWR VPWR sky130_fd_sc_hd__decap_3
XFILLER_20_324 VGND VGND VPWR VPWR sky130_fd_sc_hd__decap_3
XFILLER_32_151 VGND VGND VPWR VPWR sky130_fd_sc_hd__decap_3
XFILLER_33_685 VGND VGND VPWR VPWR sky130_fd_sc_hd__decap_3
X_6602_ _6631_/A VGND VGND VPWR VPWR _6602_/Y sky130_fd_sc_hd__inv_2
XTAP_TAPCELL_ROW_82_1288 VGND VPWR sky130_fd_sc_hd__tapvpwrvgnd_1
XTAP_TAPCELL_ROW_82_1277 VGND VPWR sky130_fd_sc_hd__tapvpwrvgnd_1
XFILLER_20_346 VGND VGND VPWR VPWR sky130_fd_sc_hd__decap_3
XFILLER_60_493 VGND VGND VPWR VPWR sky130_fd_sc_hd__fill_1
X_3814_ _3814_/A1 _3857_/A2 _3813_/Y VGND VGND VPWR VPWR _7391_/D sky130_fd_sc_hd__a21bo_2
XFILLER_20_368 VGND VGND VPWR VPWR sky130_fd_sc_hd__decap_3
X_6533_ _6533_/A VGND VGND VPWR VPWR _6533_/Y sky130_fd_sc_hd__inv_2
X_3745_ _6978_/Q _3651_/Y _3665_/X _6723_/Q _3744_/X VGND VGND VPWR VPWR _3745_/X
+ sky130_fd_sc_hd__a221o_2
X_6464_ _6535_/A VGND VGND VPWR VPWR _6464_/Y sky130_fd_sc_hd__inv_2
XFILLER_9_380 VGND VGND VPWR VPWR sky130_fd_sc_hd__decap_3
XFILLER_106_407 VGND VGND VPWR VPWR sky130_fd_sc_hd__decap_3
X_5415_ _5415_/A0 _5121_/X _5427_/S VGND VGND VPWR VPWR _7126_/D sky130_fd_sc_hd__mux2_2
X_3676_ _6716_/Q VGND VGND VPWR VPWR _3676_/Y sky130_fd_sc_hd__inv_2
X_6395_ _6556_/A VGND VGND VPWR VPWR _6395_/Y sky130_fd_sc_hd__inv_2
XFILLER_114_440 VGND VGND VPWR VPWR sky130_fd_sc_hd__fill_1
XFILLER_87_302 VGND VGND VPWR VPWR sky130_fd_sc_hd__decap_3
X_5346_ _5346_/A0 _5121_/X _5360_/S VGND VGND VPWR VPWR _7158_/D sky130_fd_sc_hd__mux2_2
XFILLER_99_151 VGND VGND VPWR VPWR sky130_fd_sc_hd__decap_3
XFILLER_87_335 VGND VGND VPWR VPWR sky130_fd_sc_hd__fill_1
XFILLER_101_134 VGND VGND VPWR VPWR sky130_fd_sc_hd__decap_3
XFILLER_102_657 VGND VGND VPWR VPWR sky130_fd_sc_hd__decap_3
XFILLER_87_346 VGND VGND VPWR VPWR sky130_fd_sc_hd__decap_3
X_7016_ _7322_/CLK _7016_/D _6296_/Y VGND VGND VPWR VPWR _7016_/Q sky130_fd_sc_hd__dfrtp_2
X_4228_ _7014_/Q _4601_/S _3975_/S _7195_/Q _4227_/X VGND VGND VPWR VPWR _4228_/X
+ sky130_fd_sc_hd__a221o_2
XFILLER_101_167 VGND VGND VPWR VPWR sky130_fd_sc_hd__fill_1
XFILLER_101_178 VGND VGND VPWR VPWR sky130_fd_sc_hd__decap_3
XFILLER_28_413 VGND VGND VPWR VPWR sky130_fd_sc_hd__decap_3
XFILLER_68_593 VGND VGND VPWR VPWR sky130_fd_sc_hd__fill_1
XFILLER_110_690 VGND VGND VPWR VPWR sky130_fd_sc_hd__decap_3
XFILLER_46_59 VGND VGND VPWR VPWR sky130_fd_sc_hd__fill_2
XFILLER_55_221 VGND VGND VPWR VPWR sky130_fd_sc_hd__decap_3
X_4159_ _7329_/Q _3964_/S _4338_/B1 _7361_/Q _4248_/A VGND VGND VPWR VPWR _4159_/X
+ sky130_fd_sc_hd__a221o_2
XPHY_EDGE_ROW_106_Right_106 VGND VGND VPWR VPWR sky130_fd_sc_hd__decap_3
XFILLER_102_21 VGND VGND VPWR VPWR sky130_fd_sc_hd__decap_3
XFILLER_16_619 VGND VGND VPWR VPWR sky130_fd_sc_hd__decap_3
XFILLER_43_405 VGND VGND VPWR VPWR sky130_fd_sc_hd__decap_3
XFILLER_55_276 VGND VGND VPWR VPWR sky130_fd_sc_hd__decap_3
XFILLER_71_703 VGND VGND VPWR VPWR sky130_fd_sc_hd__decap_3
XFILLER_83_585 VGND VGND VPWR VPWR sky130_fd_sc_hd__decap_3
XFILLER_102_32 VGND VGND VPWR VPWR sky130_fd_sc_hd__decap_3
XFILLER_102_43 VGND VGND VPWR VPWR sky130_fd_sc_hd__decap_3
XFILLER_43_449 VGND VGND VPWR VPWR sky130_fd_sc_hd__decap_3
XFILLER_55_287 VGND VGND VPWR VPWR sky130_fd_sc_hd__decap_3
XFILLER_70_224 VGND VGND VPWR VPWR sky130_fd_sc_hd__decap_3
XTAP_TAPCELL_ROW_54_934 VGND VPWR sky130_fd_sc_hd__tapvpwrvgnd_1
XFILLER_24_663 VGND VGND VPWR VPWR sky130_fd_sc_hd__decap_3
Xclkbuf_leaf_35_clk clkbuf_3_2__f_clk/X VGND VGND VPWR VPWR _7349_/CLK sky130_fd_sc_hd__clkbuf_16
XFILLER_11_313 VGND VGND VPWR VPWR sky130_fd_sc_hd__decap_3
XFILLER_24_696 VGND VGND VPWR VPWR sky130_fd_sc_hd__decap_3
XFILLER_51_460 VGND VGND VPWR VPWR sky130_fd_sc_hd__decap_3
XFILLER_11_335 VGND VGND VPWR VPWR sky130_fd_sc_hd__fill_1
XFILLER_23_184 VGND VGND VPWR VPWR sky130_fd_sc_hd__decap_3
XTAP_TAPCELL_ROW_34_680 VGND VPWR sky130_fd_sc_hd__tapvpwrvgnd_1
XFILLER_109_223 VGND VGND VPWR VPWR sky130_fd_sc_hd__fill_1
XFILLER_11_379 VGND VGND VPWR VPWR sky130_fd_sc_hd__decap_3
XPHY_EDGE_ROW_12_Left_132 VGND VGND VPWR VPWR sky130_fd_sc_hd__decap_3
XFILLER_109_234 VGND VGND VPWR VPWR sky130_fd_sc_hd__fill_1
XFILLER_109_278 VGND VGND VPWR VPWR sky130_fd_sc_hd__fill_2
XFILLER_3_523 VGND VGND VPWR VPWR sky130_fd_sc_hd__decap_3
XFILLER_105_440 VGND VGND VPWR VPWR sky130_fd_sc_hd__decap_3
XFILLER_3_556 VGND VGND VPWR VPWR sky130_fd_sc_hd__decap_3
XFILLER_3_567 VGND VGND VPWR VPWR sky130_fd_sc_hd__decap_3
XFILLER_87_11 VGND VGND VPWR VPWR sky130_fd_sc_hd__fill_1
XFILLER_105_495 VGND VGND VPWR VPWR sky130_fd_sc_hd__decap_3
XFILLER_87_55 VGND VGND VPWR VPWR sky130_fd_sc_hd__fill_1
XFILLER_66_508 VGND VGND VPWR VPWR sky130_fd_sc_hd__decap_3
XFILLER_47_700 VGND VGND VPWR VPWR sky130_fd_sc_hd__decap_3
XFILLER_93_305 VGND VGND VPWR VPWR sky130_fd_sc_hd__decap_3
XPHY_EDGE_ROW_21_Left_141 VGND VGND VPWR VPWR sky130_fd_sc_hd__decap_3
XFILLER_46_232 VGND VGND VPWR VPWR sky130_fd_sc_hd__fill_2
XFILLER_93_349 VGND VGND VPWR VPWR sky130_fd_sc_hd__fill_1
XTAP_TAPCELL_ROW_109_1623 VGND VPWR sky130_fd_sc_hd__tapvpwrvgnd_1
XFILLER_19_479 VGND VGND VPWR VPWR sky130_fd_sc_hd__decap_3
XFILLER_74_552 VGND VGND VPWR VPWR sky130_fd_sc_hd__decap_3
XFILLER_27_490 VGND VGND VPWR VPWR sky130_fd_sc_hd__fill_1
XFILLER_46_298 VGND VGND VPWR VPWR sky130_fd_sc_hd__decap_3
XFILLER_61_213 VGND VGND VPWR VPWR sky130_fd_sc_hd__decap_3
XFILLER_15_641 VGND VGND VPWR VPWR sky130_fd_sc_hd__decap_3
Xclkbuf_leaf_26_clk clkbuf_3_6__f_clk/X VGND VGND VPWR VPWR _7362_/CLK sky130_fd_sc_hd__clkbuf_16
XFILLER_14_162 VGND VGND VPWR VPWR sky130_fd_sc_hd__decap_3
XFILLER_15_685 VGND VGND VPWR VPWR sky130_fd_sc_hd__decap_3
XFILLER_30_622 VGND VGND VPWR VPWR sky130_fd_sc_hd__decap_3
XFILLER_42_460 VGND VGND VPWR VPWR sky130_fd_sc_hd__decap_3
XFILLER_14_184 VGND VGND VPWR VPWR sky130_fd_sc_hd__decap_3
XPHY_EDGE_ROW_30_Left_150 VGND VGND VPWR VPWR sky130_fd_sc_hd__decap_3
XFILLER_30_666 VGND VGND VPWR VPWR sky130_fd_sc_hd__decap_3
XFILLER_30_699 VGND VGND VPWR VPWR sky130_fd_sc_hd__fill_1
XFILLER_6_361 VGND VGND VPWR VPWR sky130_fd_sc_hd__decap_3
Xhold807 _6959_/Q VGND VGND VPWR VPWR _6959_/D sky130_fd_sc_hd__dlygate4sd3_1
Xhold818 _6861_/Q VGND VGND VPWR VPWR _6861_/D sky130_fd_sc_hd__dlygate4sd3_1
Xhold829 _6955_/Q VGND VGND VPWR VPWR _6955_/D sky130_fd_sc_hd__dlygate4sd3_1
X_3461_ _7281_/Q _4532_/S _4339_/B1 _7153_/Q _3460_/X VGND VGND VPWR VPWR _3461_/X
+ sky130_fd_sc_hd__a221o_2
XFILLER_42_3 VGND VGND VPWR VPWR sky130_fd_sc_hd__decap_3
XFILLER_69_302 VGND VGND VPWR VPWR sky130_fd_sc_hd__decap_3
XFILLER_97_611 VGND VGND VPWR VPWR sky130_fd_sc_hd__decap_3
X_5200_ _5200_/A _5207_/B VGND VGND VPWR VPWR _7228_/D sky130_fd_sc_hd__and2_2
X_3392_ _3429_/A _3429_/B VGND VGND VPWR VPWR _3591_/A sky130_fd_sc_hd__nor2_2
XFILLER_97_644 VGND VGND VPWR VPWR sky130_fd_sc_hd__decap_3
X_5131_ _3992_/Y _5128_/Y _6982_/D _5156_/S VGND VGND VPWR VPWR _5131_/X sky130_fd_sc_hd__o22a_2
XFILLER_57_508 VGND VGND VPWR VPWR sky130_fd_sc_hd__decap_3
XFILLER_69_346 VGND VGND VPWR VPWR sky130_fd_sc_hd__decap_3
XTAP_TAPCELL_ROW_4_309 VGND VPWR sky130_fd_sc_hd__tapvpwrvgnd_1
XFILLER_69_379 VGND VGND VPWR VPWR sky130_fd_sc_hd__decap_3
XFILLER_84_316 VGND VGND VPWR VPWR sky130_fd_sc_hd__fill_2
XFILLER_96_165 VGND VGND VPWR VPWR sky130_fd_sc_hd__decap_3
XFILLER_97_688 VGND VGND VPWR VPWR sky130_fd_sc_hd__decap_3
XFILLER_37_221 VGND VGND VPWR VPWR sky130_fd_sc_hd__decap_3
XFILLER_84_338 VGND VGND VPWR VPWR sky130_fd_sc_hd__decap_3
XFILLER_37_254 VGND VGND VPWR VPWR sky130_fd_sc_hd__decap_3
XFILLER_37_276 VGND VGND VPWR VPWR sky130_fd_sc_hd__decap_3
XFILLER_53_703 VGND VGND VPWR VPWR sky130_fd_sc_hd__decap_3
XTAP_TAPCELL_ROW_84_1306 VGND VPWR sky130_fd_sc_hd__tapvpwrvgnd_1
XFILLER_37_298 VGND VGND VPWR VPWR sky130_fd_sc_hd__decap_3
XFILLER_52_224 VGND VGND VPWR VPWR sky130_fd_sc_hd__decap_3
XFILLER_80_533 VGND VGND VPWR VPWR sky130_fd_sc_hd__fill_2
XFILLER_92_382 VGND VGND VPWR VPWR sky130_fd_sc_hd__decap_3
XFILLER_80_577 VGND VGND VPWR VPWR sky130_fd_sc_hd__decap_3
Xclkbuf_leaf_17_clk clkload1/A VGND VGND VPWR VPWR _7400_/CLK sky130_fd_sc_hd__clkbuf_16
XFILLER_21_600 VGND VGND VPWR VPWR sky130_fd_sc_hd__decap_3
XFILLER_33_471 VGND VGND VPWR VPWR sky130_fd_sc_hd__decap_3
XFILLER_52_279 VGND VGND VPWR VPWR sky130_fd_sc_hd__decap_3
XFILLER_21_644 VGND VGND VPWR VPWR sky130_fd_sc_hd__decap_3
X_4846_ _4903_/A _4890_/B VGND VGND VPWR VPWR _4884_/A sky130_fd_sc_hd__nand2_2
XFILLER_21_688 VGND VGND VPWR VPWR sky130_fd_sc_hd__decap_3
XTAP_TAPCELL_ROW_31_650 VGND VPWR sky130_fd_sc_hd__tapvpwrvgnd_1
XFILLER_119_554 VGND VGND VPWR VPWR sky130_fd_sc_hd__decap_3
X_6516_ _6544_/A VGND VGND VPWR VPWR _6516_/Y sky130_fd_sc_hd__inv_2
X_4777_ _4777_/A _4777_/B _4777_/C VGND VGND VPWR VPWR _4777_/X sky130_fd_sc_hd__and3_2
XFILLER_113_9 VGND VGND VPWR VPWR sky130_fd_sc_hd__decap_3
XFILLER_119_576 VGND VGND VPWR VPWR sky130_fd_sc_hd__decap_3
XFILLER_4_309 VGND VGND VPWR VPWR sky130_fd_sc_hd__decap_3
X_3728_ _3746_/A _3728_/B VGND VGND VPWR VPWR _3728_/Y sky130_fd_sc_hd__nor2_2
XTAP_TAPCELL_ROW_95_1446 VGND VPWR sky130_fd_sc_hd__tapvpwrvgnd_1
X_6447_ _6641_/A VGND VGND VPWR VPWR _6447_/Y sky130_fd_sc_hd__inv_2
XFILLER_106_259 VGND VGND VPWR VPWR sky130_fd_sc_hd__decap_3
X_6378_ _6570_/A VGND VGND VPWR VPWR _6378_/Y sky130_fd_sc_hd__inv_2
XFILLER_102_421 VGND VGND VPWR VPWR sky130_fd_sc_hd__fill_2
XFILLER_114_270 VGND VGND VPWR VPWR sky130_fd_sc_hd__fill_2
XFILLER_88_633 VGND VGND VPWR VPWR sky130_fd_sc_hd__decap_3
X_5329_ _5329_/A0 _4997_/X _5340_/S VGND VGND VPWR VPWR _7166_/D sky130_fd_sc_hd__mux2_2
XFILLER_102_432 VGND VGND VPWR VPWR sky130_fd_sc_hd__decap_3
XFILLER_114_292 VGND VGND VPWR VPWR sky130_fd_sc_hd__decap_3
XFILLER_87_143 VGND VGND VPWR VPWR sky130_fd_sc_hd__decap_3
XFILLER_88_666 VGND VGND VPWR VPWR sky130_fd_sc_hd__decap_3
XFILLER_29_700 VGND VGND VPWR VPWR sky130_fd_sc_hd__decap_3
XFILLER_57_69 VGND VGND VPWR VPWR sky130_fd_sc_hd__decap_3
XFILLER_87_165 VGND VGND VPWR VPWR sky130_fd_sc_hd__decap_3
XFILLER_87_187 VGND VGND VPWR VPWR sky130_fd_sc_hd__decap_3
XFILLER_88_699 VGND VGND VPWR VPWR sky130_fd_sc_hd__fill_1
XFILLER_28_221 VGND VGND VPWR VPWR sky130_fd_sc_hd__decap_3
XFILLER_113_53 VGND VGND VPWR VPWR sky130_fd_sc_hd__decap_3
XFILLER_16_405 VGND VGND VPWR VPWR sky130_fd_sc_hd__decap_3
XTAP_TAPCELL_ROW_39_750 VGND VPWR sky130_fd_sc_hd__tapvpwrvgnd_1
XFILLER_113_75 VGND VGND VPWR VPWR sky130_fd_sc_hd__decap_3
XFILLER_43_202 VGND VGND VPWR VPWR sky130_fd_sc_hd__decap_3
XFILLER_43_268 VGND VGND VPWR VPWR sky130_fd_sc_hd__fill_2
XFILLER_71_544 VGND VGND VPWR VPWR sky130_fd_sc_hd__decap_3
XFILLER_71_577 VGND VGND VPWR VPWR sky130_fd_sc_hd__decap_3
XFILLER_73_57 VGND VGND VPWR VPWR sky130_fd_sc_hd__decap_3
XFILLER_12_622 VGND VGND VPWR VPWR sky130_fd_sc_hd__decap_3
XFILLER_24_460 VGND VGND VPWR VPWR sky130_fd_sc_hd__decap_3
XTAP_TAPCELL_ROW_104_1564 VGND VPWR sky130_fd_sc_hd__tapvpwrvgnd_1
XTAP_TAPCELL_ROW_104_1553 VGND VPWR sky130_fd_sc_hd__tapvpwrvgnd_1
XFILLER_51_290 VGND VGND VPWR VPWR sky130_fd_sc_hd__decap_3
XFILLER_8_604 VGND VGND VPWR VPWR sky130_fd_sc_hd__decap_3
XFILLER_11_143 VGND VGND VPWR VPWR sky130_fd_sc_hd__decap_3
XFILLER_12_666 VGND VGND VPWR VPWR sky130_fd_sc_hd__decap_3
XFILLER_8_637 VGND VGND VPWR VPWR sky130_fd_sc_hd__decap_3
XFILLER_12_699 VGND VGND VPWR VPWR sky130_fd_sc_hd__fill_1
XFILLER_7_147 VGND VGND VPWR VPWR sky130_fd_sc_hd__decap_3
XFILLER_8_648 VGND VGND VPWR VPWR sky130_fd_sc_hd__decap_3
XFILLER_22_83 VGND VGND VPWR VPWR sky130_fd_sc_hd__fill_1
XFILLER_7_169 VGND VGND VPWR VPWR sky130_fd_sc_hd__decap_3
XFILLER_3_331 VGND VGND VPWR VPWR sky130_fd_sc_hd__decap_3
XFILLER_98_419 VGND VGND VPWR VPWR sky130_fd_sc_hd__fill_1
XFILLER_3_364 VGND VGND VPWR VPWR sky130_fd_sc_hd__fill_2
XTAP_TAPCELL_ROW_115_1693 VGND VPWR sky130_fd_sc_hd__tapvpwrvgnd_1
XFILLER_39_508 VGND VGND VPWR VPWR sky130_fd_sc_hd__decap_3
XFILLER_78_121 VGND VGND VPWR VPWR sky130_fd_sc_hd__decap_3
XFILLER_79_644 VGND VGND VPWR VPWR sky130_fd_sc_hd__decap_3
XFILLER_78_187 VGND VGND VPWR VPWR sky130_fd_sc_hd__decap_3
XFILLER_79_688 VGND VGND VPWR VPWR sky130_fd_sc_hd__decap_3
XFILLER_93_102 VGND VGND VPWR VPWR sky130_fd_sc_hd__decap_3
XFILLER_93_113 VGND VGND VPWR VPWR sky130_fd_sc_hd__decap_3
XFILLER_94_625 VGND VGND VPWR VPWR sky130_fd_sc_hd__decap_3
XFILLER_93_146 VGND VGND VPWR VPWR sky130_fd_sc_hd__decap_3
XFILLER_94_669 VGND VGND VPWR VPWR sky130_fd_sc_hd__decap_3
XFILLER_19_243 VGND VGND VPWR VPWR sky130_fd_sc_hd__fill_2
XFILLER_19_265 VGND VGND VPWR VPWR sky130_fd_sc_hd__decap_3
XFILLER_35_703 VGND VGND VPWR VPWR sky130_fd_sc_hd__decap_3
XFILLER_47_91 VGND VGND VPWR VPWR sky130_fd_sc_hd__decap_3
XFILLER_74_360 VGND VGND VPWR VPWR sky130_fd_sc_hd__decap_3
XFILLER_81_319 VGND VGND VPWR VPWR sky130_fd_sc_hd__decap_3
XFILLER_19_287 VGND VGND VPWR VPWR sky130_fd_sc_hd__decap_3
XFILLER_62_522 VGND VGND VPWR VPWR sky130_fd_sc_hd__decap_3
XFILLER_74_371 VGND VGND VPWR VPWR sky130_fd_sc_hd__decap_3
XFILLER_22_408 VGND VGND VPWR VPWR sky130_fd_sc_hd__decap_3
XFILLER_34_235 VGND VGND VPWR VPWR sky130_fd_sc_hd__decap_3
XFILLER_62_566 VGND VGND VPWR VPWR sky130_fd_sc_hd__fill_1
XFILLER_62_599 VGND VGND VPWR VPWR sky130_fd_sc_hd__fill_1
XTAP_TAPCELL_ROW_17_466 VGND VPWR sky130_fd_sc_hd__tapvpwrvgnd_1
XFILLER_15_482 VGND VGND VPWR VPWR sky130_fd_sc_hd__fill_1
XFILLER_30_430 VGND VGND VPWR VPWR sky130_fd_sc_hd__decap_3
XFILLER_42_290 VGND VGND VPWR VPWR sky130_fd_sc_hd__decap_3
XFILLER_63_90 VGND VGND VPWR VPWR sky130_fd_sc_hd__decap_3
X_5680_ _7346_/Q _6690_/Q _5708_/S VGND VGND VPWR VPWR _6690_/D sky130_fd_sc_hd__mux2_2
X_4700_ _6988_/Q _5066_/A VGND VGND VPWR VPWR _5044_/A sky130_fd_sc_hd__and2_2
X_4631_ _5003_/A _4275_/Y _4630_/X _4275_/A VGND VGND VPWR VPWR _4631_/X sky130_fd_sc_hd__a31o_2
XFILLER_8_63 VGND VGND VPWR VPWR sky130_fd_sc_hd__fill_2
XFILLER_8_85 VGND VGND VPWR VPWR sky130_fd_sc_hd__decap_3
X_7350_ _7350_/CLK _7350_/D _6630_/Y VGND VGND VPWR VPWR _7350_/Q sky130_fd_sc_hd__dfrtp_2
X_7281_ _7313_/CLK _7281_/D _6561_/Y VGND VGND VPWR VPWR _7281_/Q sky130_fd_sc_hd__dfrtp_2
X_6301_ _6612_/A VGND VGND VPWR VPWR _6301_/Y sky130_fd_sc_hd__inv_2
X_4493_ _4493_/A0 _7301_/Q _4497_/S VGND VGND VPWR VPWR _7333_/D sky130_fd_sc_hd__mux2_2
XFILLER_116_579 VGND VGND VPWR VPWR sky130_fd_sc_hd__decap_3
Xclkbuf_leaf_6_clk clkbuf_leaf_6_clk/A VGND VGND VPWR VPWR _6922_/CLK sky130_fd_sc_hd__clkbuf_16
XFILLER_69_143 VGND VGND VPWR VPWR sky130_fd_sc_hd__decap_3
XFILLER_97_452 VGND VGND VPWR VPWR sky130_fd_sc_hd__decap_3
X_3375_ _5118_/A _3399_/B VGND VGND VPWR VPWR _5641_/A sky130_fd_sc_hd__nand2_2
XFILLER_111_262 VGND VGND VPWR VPWR sky130_fd_sc_hd__decap_3
XFILLER_85_614 VGND VGND VPWR VPWR sky130_fd_sc_hd__fill_2
XFILLER_97_474 VGND VGND VPWR VPWR sky130_fd_sc_hd__decap_3
Xhold1304 _7267_/Q VGND VGND VPWR VPWR _4914_/A0 sky130_fd_sc_hd__dlygate4sd3_1
Xhold1315 _7141_/Q VGND VGND VPWR VPWR _5383_/A0 sky130_fd_sc_hd__dlygate4sd3_1
X_5114_ _5114_/A _5114_/B VGND VGND VPWR VPWR _5114_/Y sky130_fd_sc_hd__nand2_2
XTAP_TAPCELL_ROW_90_1387 VGND VPWR sky130_fd_sc_hd__tapvpwrvgnd_1
XFILLER_111_284 VGND VGND VPWR VPWR sky130_fd_sc_hd__decap_3
XFILLER_69_198 VGND VGND VPWR VPWR sky130_fd_sc_hd__decap_3
XFILLER_84_124 VGND VGND VPWR VPWR sky130_fd_sc_hd__decap_3
XFILLER_85_647 VGND VGND VPWR VPWR sky130_fd_sc_hd__decap_3
X_5045_ _6988_/Q _5045_/B VGND VGND VPWR VPWR _5045_/X sky130_fd_sc_hd__or2_2
XFILLER_38_574 VGND VGND VPWR VPWR sky130_fd_sc_hd__decap_3
XFILLER_84_157 VGND VGND VPWR VPWR sky130_fd_sc_hd__fill_2
XFILLER_84_179 VGND VGND VPWR VPWR sky130_fd_sc_hd__decap_3
XFILLER_25_202 VGND VGND VPWR VPWR sky130_fd_sc_hd__fill_1
XFILLER_38_585 VGND VGND VPWR VPWR sky130_fd_sc_hd__decap_3
XFILLER_65_360 VGND VGND VPWR VPWR sky130_fd_sc_hd__decap_3
XFILLER_65_393 VGND VGND VPWR VPWR sky130_fd_sc_hd__fill_2
XFILLER_93_691 VGND VGND VPWR VPWR sky130_fd_sc_hd__decap_3
XFILLER_25_235 VGND VGND VPWR VPWR sky130_fd_sc_hd__decap_3
XFILLER_41_706 VGND VGND VPWR VPWR sky130_fd_sc_hd__decap_3
XFILLER_53_555 VGND VGND VPWR VPWR sky130_fd_sc_hd__fill_1
XFILLER_80_330 VGND VGND VPWR VPWR sky130_fd_sc_hd__decap_3
X_6996_ _7371_/CLK _6996_/D _6276_/Y VGND VGND VPWR VPWR _6996_/Q sky130_fd_sc_hd__dfrtp_2
XFILLER_25_268 VGND VGND VPWR VPWR sky130_fd_sc_hd__decap_3
XFILLER_33_290 VGND VGND VPWR VPWR sky130_fd_sc_hd__decap_3
XFILLER_40_227 VGND VGND VPWR VPWR sky130_fd_sc_hd__decap_3
XFILLER_21_452 VGND VGND VPWR VPWR sky130_fd_sc_hd__decap_3
X_4829_ _4948_/A _4829_/B VGND VGND VPWR VPWR _4829_/Y sky130_fd_sc_hd__nor2_2
XFILLER_107_513 VGND VGND VPWR VPWR sky130_fd_sc_hd__fill_2
XFILLER_119_340 VGND VGND VPWR VPWR sky130_fd_sc_hd__fill_2
XFILLER_5_629 VGND VGND VPWR VPWR sky130_fd_sc_hd__decap_3
XFILLER_111_6 VGND VGND VPWR VPWR sky130_fd_sc_hd__decap_3
XFILLER_119_384 VGND VGND VPWR VPWR sky130_fd_sc_hd__decap_3
XFILLER_108_53 VGND VGND VPWR VPWR sky130_fd_sc_hd__decap_3
XFILLER_0_312 VGND VGND VPWR VPWR sky130_fd_sc_hd__decap_3
XFILLER_115_590 VGND VGND VPWR VPWR sky130_fd_sc_hd__decap_3
XFILLER_88_430 VGND VGND VPWR VPWR sky130_fd_sc_hd__decap_3
XFILLER_0_389 VGND VGND VPWR VPWR sky130_fd_sc_hd__decap_3
XFILLER_102_262 VGND VGND VPWR VPWR sky130_fd_sc_hd__decap_3
XFILLER_88_463 VGND VGND VPWR VPWR sky130_fd_sc_hd__decap_3
XFILLER_75_135 VGND VGND VPWR VPWR sky130_fd_sc_hd__decap_3
XFILLER_76_636 VGND VGND VPWR VPWR sky130_fd_sc_hd__decap_3
XFILLER_76_669 VGND VGND VPWR VPWR sky130_fd_sc_hd__decap_3
XFILLER_84_12 VGND VGND VPWR VPWR sky130_fd_sc_hd__decap_3
XFILLER_17_703 VGND VGND VPWR VPWR sky130_fd_sc_hd__decap_3
XFILLER_63_319 VGND VGND VPWR VPWR sky130_fd_sc_hd__fill_1
XFILLER_91_617 VGND VGND VPWR VPWR sky130_fd_sc_hd__decap_3
XFILLER_29_585 VGND VGND VPWR VPWR sky130_fd_sc_hd__decap_3
XFILLER_44_511 VGND VGND VPWR VPWR sky130_fd_sc_hd__fill_1
XFILLER_44_522 VGND VGND VPWR VPWR sky130_fd_sc_hd__decap_3
XFILLER_44_533 VGND VGND VPWR VPWR sky130_fd_sc_hd__fill_2
XFILLER_84_78 VGND VGND VPWR VPWR sky130_fd_sc_hd__decap_3
Xplace319 _5658_/D VGND VGND VPWR VPWR _5117_/B sky130_fd_sc_hd__buf_2
XFILLER_71_352 VGND VGND VPWR VPWR sky130_fd_sc_hd__decap_3
XFILLER_83_190 VGND VGND VPWR VPWR sky130_fd_sc_hd__decap_3
XFILLER_16_268 VGND VGND VPWR VPWR sky130_fd_sc_hd__decap_3
XFILLER_31_205 VGND VGND VPWR VPWR sky130_fd_sc_hd__decap_3
XFILLER_71_396 VGND VGND VPWR VPWR sky130_fd_sc_hd__decap_3
XTAP_TAPCELL_ROW_14_436 VGND VPWR sky130_fd_sc_hd__tapvpwrvgnd_1
XTAP_TAPCELL_ROW_42_789 VGND VPWR sky130_fd_sc_hd__tapvpwrvgnd_1
XTAP_TAPCELL_ROW_42_778 VGND VPWR sky130_fd_sc_hd__tapvpwrvgnd_1
XFILLER_76_9 VGND VGND VPWR VPWR sky130_fd_sc_hd__decap_3
XTAP_TAPCELL_ROW_117_1722 VGND VPWR sky130_fd_sc_hd__tapvpwrvgnd_1
XFILLER_4_651 VGND VGND VPWR VPWR sky130_fd_sc_hd__decap_3
XFILLER_99_706 VGND VGND VPWR VPWR sky130_fd_sc_hd__decap_3
XFILLER_4_684 VGND VGND VPWR VPWR sky130_fd_sc_hd__decap_3
XFILLER_98_216 VGND VGND VPWR VPWR sky130_fd_sc_hd__decap_3
XFILLER_79_452 VGND VGND VPWR VPWR sky130_fd_sc_hd__decap_3
XFILLER_39_316 VGND VGND VPWR VPWR sky130_fd_sc_hd__fill_1
XFILLER_67_603 VGND VGND VPWR VPWR sky130_fd_sc_hd__decap_3
XFILLER_79_485 VGND VGND VPWR VPWR sky130_fd_sc_hd__decap_3
XFILLER_66_113 VGND VGND VPWR VPWR sky130_fd_sc_hd__fill_1
XFILLER_66_124 VGND VGND VPWR VPWR sky130_fd_sc_hd__fill_1
XFILLER_67_647 VGND VGND VPWR VPWR sky130_fd_sc_hd__decap_3
XFILLER_94_433 VGND VGND VPWR VPWR sky130_fd_sc_hd__fill_1
XFILLER_82_628 VGND VGND VPWR VPWR sky130_fd_sc_hd__decap_3
XTAP_TAPCELL_ROW_68_1109 VGND VPWR sky130_fd_sc_hd__tapvpwrvgnd_1
XFILLER_35_500 VGND VGND VPWR VPWR sky130_fd_sc_hd__decap_3
XFILLER_75_691 VGND VGND VPWR VPWR sky130_fd_sc_hd__decap_3
XFILLER_81_116 VGND VGND VPWR VPWR sky130_fd_sc_hd__decap_3
XFILLER_23_706 VGND VGND VPWR VPWR sky130_fd_sc_hd__decap_3
XFILLER_47_393 VGND VGND VPWR VPWR sky130_fd_sc_hd__decap_3
XFILLER_81_149 VGND VGND VPWR VPWR sky130_fd_sc_hd__decap_3
X_6850_ _6906_/CLK _6850_/D VGND VGND VPWR VPWR _6850_/Q sky130_fd_sc_hd__dfxtp_2
XFILLER_22_216 VGND VGND VPWR VPWR sky130_fd_sc_hd__fill_2
XFILLER_35_588 VGND VGND VPWR VPWR sky130_fd_sc_hd__decap_3
XFILLER_90_672 VGND VGND VPWR VPWR sky130_fd_sc_hd__decap_3
X_6781_ clkload8/A _6781_/D VGND VGND VPWR VPWR _6781_/Q sky130_fd_sc_hd__dfxtp_2
XPHY_EDGE_ROW_8_Right_8 VGND VGND VPWR VPWR sky130_fd_sc_hd__decap_3
X_3993_ _4467_/B _3919_/X _3991_/X _3992_/Y VGND VGND VPWR VPWR _3993_/X sky130_fd_sc_hd__a31o_2
XFILLER_15_290 VGND VGND VPWR VPWR sky130_fd_sc_hd__decap_3
X_5663_ _5663_/A _5663_/B _5663_/C _5663_/D VGND VGND VPWR VPWR _5664_/D sky130_fd_sc_hd__nor4_2
X_7402_ _7402_/CLK _7402_/D _6682_/Y VGND VGND VPWR VPWR _7402_/Q sky130_fd_sc_hd__dfrtp_2
X_4614_ _4614_/A _4614_/B _4614_/C _5113_/A VGND VGND VPWR VPWR _4614_/X sky130_fd_sc_hd__and4_4
XTAP_TAPCELL_ROW_79_1249 VGND VPWR sky130_fd_sc_hd__tapvpwrvgnd_1
X_7333_ _7333_/CLK _7333_/D _6613_/Y VGND VGND VPWR VPWR _7333_/Q sky130_fd_sc_hd__dfrtp_2
XFILLER_116_365 VGND VGND VPWR VPWR sky130_fd_sc_hd__fill_2
XTAP_TAPCELL_ROW_92_1405 VGND VPWR sky130_fd_sc_hd__tapvpwrvgnd_1
XFILLER_89_205 VGND VGND VPWR VPWR sky130_fd_sc_hd__decap_3
X_7264_ _7358_/CLK _7264_/D _6544_/Y VGND VGND VPWR VPWR _7264_/Q sky130_fd_sc_hd__dfrtp_2
X_4476_ _4476_/A0 _7309_/Q _4497_/S VGND VGND VPWR VPWR _7341_/D sky130_fd_sc_hd__mux2_2
X_7195_ _7357_/CLK _7195_/D _6475_/Y VGND VGND VPWR VPWR _7195_/Q sky130_fd_sc_hd__dfrtp_2
X_3427_ _3527_/A _3427_/B VGND VGND VPWR VPWR _3508_/A sky130_fd_sc_hd__nand2b_2
XPHY_EDGE_ROW_39_Right_39 VGND VGND VPWR VPWR sky130_fd_sc_hd__decap_3
XFILLER_112_571 VGND VGND VPWR VPWR sky130_fd_sc_hd__decap_3
XFILLER_38_27 VGND VGND VPWR VPWR sky130_fd_sc_hd__fill_1
XFILLER_57_102 VGND VGND VPWR VPWR sky130_fd_sc_hd__decap_3
XFILLER_58_625 VGND VGND VPWR VPWR sky130_fd_sc_hd__decap_3
X_3358_ _3469_/A _3469_/B _3449_/A _3365_/A VGND VGND VPWR VPWR _4599_/S sky130_fd_sc_hd__o211a_4
XFILLER_97_271 VGND VGND VPWR VPWR sky130_fd_sc_hd__fill_1
XFILLER_97_293 VGND VGND VPWR VPWR sky130_fd_sc_hd__decap_3
Xhold1101 _7261_/Q VGND VGND VPWR VPWR _5012_/A0 sky130_fd_sc_hd__dlygate4sd3_1
Xhold1112 _7265_/Q VGND VGND VPWR VPWR _4946_/A0 sky130_fd_sc_hd__dlygate4sd3_1
Xhold1123 _7271_/Q VGND VGND VPWR VPWR _4837_/A0 sky130_fd_sc_hd__dlygate4sd3_1
XFILLER_57_146 VGND VGND VPWR VPWR sky130_fd_sc_hd__decap_3
XFILLER_58_669 VGND VGND VPWR VPWR sky130_fd_sc_hd__decap_3
XFILLER_73_617 VGND VGND VPWR VPWR sky130_fd_sc_hd__decap_3
XFILLER_85_455 VGND VGND VPWR VPWR sky130_fd_sc_hd__decap_3
Xhold1134 _7266_/Q VGND VGND VPWR VPWR _4933_/A0 sky130_fd_sc_hd__dlygate4sd3_1
Xhold1145 _7272_/Q VGND VGND VPWR VPWR _4823_/A0 sky130_fd_sc_hd__dlygate4sd3_1
Xhold1156 _7274_/Q VGND VGND VPWR VPWR _4793_/A0 sky130_fd_sc_hd__dlygate4sd3_1
Xhold1167 _4513_/X VGND VGND VPWR VPWR _7323_/D sky130_fd_sc_hd__dlygate4sd3_1
XFILLER_38_360 VGND VGND VPWR VPWR sky130_fd_sc_hd__fill_1
XFILLER_38_382 VGND VGND VPWR VPWR sky130_fd_sc_hd__decap_3
XFILLER_45_319 VGND VGND VPWR VPWR sky130_fd_sc_hd__decap_3
XFILLER_57_179 VGND VGND VPWR VPWR sky130_fd_sc_hd__decap_3
XFILLER_72_105 VGND VGND VPWR VPWR sky130_fd_sc_hd__fill_2
XFILLER_85_499 VGND VGND VPWR VPWR sky130_fd_sc_hd__decap_3
Xhold1178 _7280_/Q VGND VGND VPWR VPWR _4601_/A0 sky130_fd_sc_hd__dlygate4sd3_1
Xhold1189 _7231_/Q VGND VGND VPWR VPWR _5194_/A sky130_fd_sc_hd__dlygate4sd3_1
X_5028_ _5028_/A0 _5027_/X _5028_/S VGND VGND VPWR VPWR _7260_/D sky130_fd_sc_hd__mux2_2
XFILLER_81_650 VGND VGND VPWR VPWR sky130_fd_sc_hd__decap_3
XFILLER_13_205 VGND VGND VPWR VPWR sky130_fd_sc_hd__fill_2
XFILLER_110_32 VGND VGND VPWR VPWR sky130_fd_sc_hd__decap_3
XFILLER_53_396 VGND VGND VPWR VPWR sky130_fd_sc_hd__decap_3
XFILLER_81_694 VGND VGND VPWR VPWR sky130_fd_sc_hd__decap_3
X_6979_ _7390_/CLK _6979_/D _6259_/Y VGND VGND VPWR VPWR _6979_/Q sky130_fd_sc_hd__dfrtp_2
XTAP_TAPCELL_ROW_101_1523 VGND VPWR sky130_fd_sc_hd__tapvpwrvgnd_1
XPHY_EDGE_ROW_48_Right_48 VGND VGND VPWR VPWR sky130_fd_sc_hd__decap_3
XFILLER_110_65 VGND VGND VPWR VPWR sky130_fd_sc_hd__decap_3
XFILLER_21_260 VGND VGND VPWR VPWR sky130_fd_sc_hd__decap_3
XFILLER_70_69 VGND VGND VPWR VPWR sky130_fd_sc_hd__decap_3
XFILLER_107_321 VGND VGND VPWR VPWR sky130_fd_sc_hd__decap_3
XFILLER_107_343 VGND VGND VPWR VPWR sky130_fd_sc_hd__decap_3
XFILLER_119_192 VGND VGND VPWR VPWR sky130_fd_sc_hd__decap_3
XFILLER_119_96 VGND VGND VPWR VPWR sky130_fd_sc_hd__decap_3
XFILLER_79_12 VGND VGND VPWR VPWR sky130_fd_sc_hd__decap_3
XFILLER_79_78 VGND VGND VPWR VPWR sky130_fd_sc_hd__decap_3
XPHY_EDGE_ROW_57_Right_57 VGND VGND VPWR VPWR sky130_fd_sc_hd__decap_3
XFILLER_1_632 VGND VGND VPWR VPWR sky130_fd_sc_hd__decap_3
Xhold990 _7094_/Q VGND VGND VPWR VPWR _7094_/D sky130_fd_sc_hd__dlygate4sd3_1
XTAP_TAPCELL_ROW_112_1652 VGND VPWR sky130_fd_sc_hd__tapvpwrvgnd_1
XFILLER_110_508 VGND VGND VPWR VPWR sky130_fd_sc_hd__fill_1
XFILLER_1_665 VGND VGND VPWR VPWR sky130_fd_sc_hd__decap_3
XFILLER_1_676 VGND VGND VPWR VPWR sky130_fd_sc_hd__decap_3
XFILLER_49_614 VGND VGND VPWR VPWR sky130_fd_sc_hd__fill_2
XFILLER_95_11 VGND VGND VPWR VPWR sky130_fd_sc_hd__fill_1
XTAP_TAPCELL_ROW_112_1663 VGND VPWR sky130_fd_sc_hd__tapvpwrvgnd_1
XFILLER_48_124 VGND VGND VPWR VPWR sky130_fd_sc_hd__decap_3
XFILLER_49_647 VGND VGND VPWR VPWR sky130_fd_sc_hd__decap_3
XFILLER_88_271 VGND VGND VPWR VPWR sky130_fd_sc_hd__decap_3
XFILLER_95_55 VGND VGND VPWR VPWR sky130_fd_sc_hd__fill_1
XFILLER_95_66 VGND VGND VPWR VPWR sky130_fd_sc_hd__decap_3
XFILLER_48_157 VGND VGND VPWR VPWR sky130_fd_sc_hd__decap_3
XFILLER_76_477 VGND VGND VPWR VPWR sky130_fd_sc_hd__decap_3
XFILLER_29_382 VGND VGND VPWR VPWR sky130_fd_sc_hd__decap_3
XFILLER_57_691 VGND VGND VPWR VPWR sky130_fd_sc_hd__decap_3
XFILLER_63_105 VGND VGND VPWR VPWR sky130_fd_sc_hd__decap_3
XFILLER_63_116 VGND VGND VPWR VPWR sky130_fd_sc_hd__decap_3
XFILLER_64_628 VGND VGND VPWR VPWR sky130_fd_sc_hd__decap_3
XTAP_TAPCELL_ROW_47_848 VGND VPWR sky130_fd_sc_hd__tapvpwrvgnd_1
XFILLER_17_544 VGND VGND VPWR VPWR sky130_fd_sc_hd__decap_3
XFILLER_17_555 VGND VGND VPWR VPWR sky130_fd_sc_hd__fill_2
XFILLER_29_393 VGND VGND VPWR VPWR sky130_fd_sc_hd__decap_3
XFILLER_56_190 VGND VGND VPWR VPWR sky130_fd_sc_hd__decap_3
XFILLER_44_374 VGND VGND VPWR VPWR sky130_fd_sc_hd__decap_3
XFILLER_72_672 VGND VGND VPWR VPWR sky130_fd_sc_hd__decap_3
XPHY_EDGE_ROW_66_Right_66 VGND VGND VPWR VPWR sky130_fd_sc_hd__decap_3
XFILLER_17_599 VGND VGND VPWR VPWR sky130_fd_sc_hd__decap_3
XFILLER_32_536 VGND VGND VPWR VPWR sky130_fd_sc_hd__decap_3
XFILLER_71_193 VGND VGND VPWR VPWR sky130_fd_sc_hd__decap_3
XTAP_TAPCELL_ROW_27_594 VGND VPWR sky130_fd_sc_hd__tapvpwrvgnd_1
XPHY_EDGE_ROW_4_Left_124 VGND VGND VPWR VPWR sky130_fd_sc_hd__decap_3
XFILLER_8_220 VGND VGND VPWR VPWR sky130_fd_sc_hd__decap_3
XFILLER_118_619 VGND VGND VPWR VPWR sky130_fd_sc_hd__decap_3
XFILLER_12_293 VGND VGND VPWR VPWR sky130_fd_sc_hd__decap_3
XFILLER_8_253 VGND VGND VPWR VPWR sky130_fd_sc_hd__decap_3
XFILLER_8_264 VGND VGND VPWR VPWR sky130_fd_sc_hd__decap_3
XFILLER_60_91 VGND VGND VPWR VPWR sky130_fd_sc_hd__decap_3
XPHY_EDGE_ROW_75_Right_75 VGND VGND VPWR VPWR sky130_fd_sc_hd__decap_3
XFILLER_113_302 VGND VGND VPWR VPWR sky130_fd_sc_hd__fill_1
X_4330_ _5057_/B _4330_/B VGND VGND VPWR VPWR _4619_/B sky130_fd_sc_hd__or2_2
XFILLER_99_514 VGND VGND VPWR VPWR sky130_fd_sc_hd__decap_3
XFILLER_4_492 VGND VGND VPWR VPWR sky130_fd_sc_hd__decap_3
XFILLER_87_709 VGND VGND VPWR VPWR sky130_fd_sc_hd__decap_3
X_4261_ _7358_/Q _4261_/A2 _4421_/B1 _7166_/Q _4248_/A VGND VGND VPWR VPWR _4261_/X
+ sky130_fd_sc_hd__a221o_2
XTAP_TAPCELL_ROW_74_1179 VGND VPWR sky130_fd_sc_hd__tapvpwrvgnd_1
XFILLER_99_558 VGND VGND VPWR VPWR sky130_fd_sc_hd__fill_2
XFILLER_101_508 VGND VGND VPWR VPWR sky130_fd_sc_hd__fill_2
XFILLER_67_411 VGND VGND VPWR VPWR sky130_fd_sc_hd__decap_3
XFILLER_79_293 VGND VGND VPWR VPWR sky130_fd_sc_hd__fill_2
X_4192_ _4637_/B _4637_/C VGND VGND VPWR VPWR _4380_/A sky130_fd_sc_hd__and2_2
XFILLER_55_606 VGND VGND VPWR VPWR sky130_fd_sc_hd__decap_3
XFILLER_55_617 VGND VGND VPWR VPWR sky130_fd_sc_hd__decap_3
XFILLER_94_241 VGND VGND VPWR VPWR sky130_fd_sc_hd__decap_3
XFILLER_82_403 VGND VGND VPWR VPWR sky130_fd_sc_hd__decap_3
XFILLER_94_263 VGND VGND VPWR VPWR sky130_fd_sc_hd__decap_3
XFILLER_94_296 VGND VGND VPWR VPWR sky130_fd_sc_hd__decap_3
XPHY_EDGE_ROW_84_Right_84 VGND VGND VPWR VPWR sky130_fd_sc_hd__decap_3
XFILLER_47_190 VGND VGND VPWR VPWR sky130_fd_sc_hd__decap_3
XFILLER_54_138 VGND VGND VPWR VPWR sky130_fd_sc_hd__fill_2
XFILLER_63_650 VGND VGND VPWR VPWR sky130_fd_sc_hd__decap_3
X_6902_ _6968_/CLK _6902_/D VGND VGND VPWR VPWR _6902_/Q sky130_fd_sc_hd__dfxtp_2
XFILLER_23_514 VGND VGND VPWR VPWR sky130_fd_sc_hd__decap_3
X_6833_ clkload5/A _6833_/D VGND VGND VPWR VPWR _6833_/Q sky130_fd_sc_hd__dfxtp_2
XFILLER_23_536 VGND VGND VPWR VPWR sky130_fd_sc_hd__decap_3
XFILLER_24_29 VGND VGND VPWR VPWR sky130_fd_sc_hd__fill_1
XFILLER_35_396 VGND VGND VPWR VPWR sky130_fd_sc_hd__fill_1
XFILLER_63_694 VGND VGND VPWR VPWR sky130_fd_sc_hd__decap_3
XFILLER_90_480 VGND VGND VPWR VPWR sky130_fd_sc_hd__decap_3
XPHY_EDGE_ROW_59_Left_179 VGND VGND VPWR VPWR sky130_fd_sc_hd__decap_3
XFILLER_11_709 VGND VGND VPWR VPWR sky130_fd_sc_hd__decap_3
X_6764_ _6968_/CLK _6764_/D VGND VGND VPWR VPWR _6764_/Q sky130_fd_sc_hd__dfxtp_2
XFILLER_31_580 VGND VGND VPWR VPWR sky130_fd_sc_hd__decap_3
X_6695_ _7355_/CLK _6695_/D VGND VGND VPWR VPWR _6695_/Q sky130_fd_sc_hd__dfxtp_2
X_5715_ _7363_/Q _5715_/A1 _5735_/S VGND VGND VPWR VPWR _6707_/D sky130_fd_sc_hd__mux2_2
XFILLER_109_608 VGND VGND VPWR VPWR sky130_fd_sc_hd__decap_3
X_5646_ _5646_/A VGND VGND VPWR VPWR _5646_/Y sky130_fd_sc_hd__inv_2
XPHY_EDGE_ROW_93_Right_93 VGND VGND VPWR VPWR sky130_fd_sc_hd__decap_3
XFILLER_117_641 VGND VGND VPWR VPWR sky130_fd_sc_hd__decap_3
X_5577_ _5577_/A0 _5038_/X _5581_/S VGND VGND VPWR VPWR _7040_/D sky130_fd_sc_hd__mux2_2
XFILLER_116_162 VGND VGND VPWR VPWR sky130_fd_sc_hd__decap_3
XFILLER_117_685 VGND VGND VPWR VPWR sky130_fd_sc_hd__decap_3
X_7316_ _7350_/CLK _7316_/D _6596_/Y VGND VGND VPWR VPWR _7316_/Q sky130_fd_sc_hd__dfrtp_2
X_4528_ _4528_/A _4528_/B VGND VGND VPWR VPWR _7315_/D sky130_fd_sc_hd__or2_2
XFILLER_104_324 VGND VGND VPWR VPWR sky130_fd_sc_hd__decap_3
X_7247_ _7349_/CLK _7247_/D _6527_/Y VGND VGND VPWR VPWR _7247_/Q sky130_fd_sc_hd__dfrtp_2
X_4459_ _4040_/Y _4457_/X _4458_/X _4459_/C1 VGND VGND VPWR VPWR _5655_/B sky130_fd_sc_hd__o211a_2
XPHY_EDGE_ROW_68_Left_188 VGND VGND VPWR VPWR sky130_fd_sc_hd__decap_3
XFILLER_104_357 VGND VGND VPWR VPWR sky130_fd_sc_hd__decap_3
XFILLER_104_368 VGND VGND VPWR VPWR sky130_fd_sc_hd__decap_3
XFILLER_58_433 VGND VGND VPWR VPWR sky130_fd_sc_hd__decap_3
X_7178_ _7406_/CLK _7178_/D _6458_/Y VGND VGND VPWR VPWR _7178_/Q sky130_fd_sc_hd__dfrtp_2
XFILLER_100_530 VGND VGND VPWR VPWR sky130_fd_sc_hd__fill_2
XFILLER_58_466 VGND VGND VPWR VPWR sky130_fd_sc_hd__decap_3
XFILLER_85_252 VGND VGND VPWR VPWR sky130_fd_sc_hd__decap_3
XFILLER_46_628 VGND VGND VPWR VPWR sky130_fd_sc_hd__decap_3
XFILLER_58_477 VGND VGND VPWR VPWR sky130_fd_sc_hd__decap_3
XFILLER_58_488 VGND VGND VPWR VPWR sky130_fd_sc_hd__decap_3
XFILLER_58_499 VGND VGND VPWR VPWR sky130_fd_sc_hd__decap_3
XFILLER_73_436 VGND VGND VPWR VPWR sky130_fd_sc_hd__decap_3
XFILLER_39_691 VGND VGND VPWR VPWR sky130_fd_sc_hd__decap_3
XFILLER_73_458 VGND VGND VPWR VPWR sky130_fd_sc_hd__fill_1
XFILLER_85_296 VGND VGND VPWR VPWR sky130_fd_sc_hd__decap_3
XFILLER_26_341 VGND VGND VPWR VPWR sky130_fd_sc_hd__decap_3
XFILLER_26_363 VGND VGND VPWR VPWR sky130_fd_sc_hd__fill_1
XFILLER_54_672 VGND VGND VPWR VPWR sky130_fd_sc_hd__decap_3
XFILLER_60_108 VGND VGND VPWR VPWR sky130_fd_sc_hd__decap_3
XTAP_TAPCELL_ROW_44_807 VGND VPWR sky130_fd_sc_hd__tapvpwrvgnd_1
XPHY_EDGE_ROW_77_Left_197 VGND VGND VPWR VPWR sky130_fd_sc_hd__decap_3
XFILLER_53_182 VGND VGND VPWR VPWR sky130_fd_sc_hd__decap_3
XFILLER_81_57 VGND VGND VPWR VPWR sky130_fd_sc_hd__decap_3
XTAP_TAPCELL_ROW_24_553 VGND VPWR sky130_fd_sc_hd__tapvpwrvgnd_1
XFILLER_14_40 VGND VGND VPWR VPWR sky130_fd_sc_hd__decap_3
XFILLER_41_399 VGND VGND VPWR VPWR sky130_fd_sc_hd__decap_3
XTAP_TAPCELL_ROW_24_564 VGND VPWR sky130_fd_sc_hd__tapvpwrvgnd_1
XFILLER_6_713 VGND VGND VPWR VPWR sky130_fd_sc_hd__fill_1
XFILLER_108_663 VGND VGND VPWR VPWR sky130_fd_sc_hd__decap_3
XFILLER_5_223 VGND VGND VPWR VPWR sky130_fd_sc_hd__fill_1
XFILLER_5_245 VGND VGND VPWR VPWR sky130_fd_sc_hd__decap_3
XFILLER_107_140 VGND VGND VPWR VPWR sky130_fd_sc_hd__decap_3
XFILLER_108_696 VGND VGND VPWR VPWR sky130_fd_sc_hd__decap_3
XFILLER_5_267 VGND VGND VPWR VPWR sky130_fd_sc_hd__decap_3
XFILLER_69_709 VGND VGND VPWR VPWR sky130_fd_sc_hd__decap_3
XFILLER_96_528 VGND VGND VPWR VPWR sky130_fd_sc_hd__decap_3
XFILLER_110_327 VGND VGND VPWR VPWR sky130_fd_sc_hd__decap_3
XFILLER_1_484 VGND VGND VPWR VPWR sky130_fd_sc_hd__decap_3
XFILLER_103_390 VGND VGND VPWR VPWR sky130_fd_sc_hd__fill_2
XFILLER_92_701 VGND VGND VPWR VPWR sky130_fd_sc_hd__decap_3
XFILLER_37_617 VGND VGND VPWR VPWR sky130_fd_sc_hd__decap_3
XFILLER_49_488 VGND VGND VPWR VPWR sky130_fd_sc_hd__fill_1
XFILLER_29_190 VGND VGND VPWR VPWR sky130_fd_sc_hd__decap_3
XFILLER_45_650 VGND VGND VPWR VPWR sky130_fd_sc_hd__decap_3
XFILLER_91_288 VGND VGND VPWR VPWR sky130_fd_sc_hd__decap_3
XFILLER_17_396 VGND VGND VPWR VPWR sky130_fd_sc_hd__decap_3
XFILLER_45_694 VGND VGND VPWR VPWR sky130_fd_sc_hd__decap_3
XFILLER_60_631 VGND VGND VPWR VPWR sky130_fd_sc_hd__decap_3
XFILLER_44_193 VGND VGND VPWR VPWR sky130_fd_sc_hd__decap_3
XFILLER_60_675 VGND VGND VPWR VPWR sky130_fd_sc_hd__decap_3
X_3830_ _6860_/Q _3922_/A2 _3913_/B1 _6852_/Q _3829_/X VGND VGND VPWR VPWR _3830_/X
+ sky130_fd_sc_hd__a221o_2
XFILLER_13_591 VGND VGND VPWR VPWR sky130_fd_sc_hd__decap_3
XFILLER_9_551 VGND VGND VPWR VPWR sky130_fd_sc_hd__decap_3
XFILLER_72_3 VGND VGND VPWR VPWR sky130_fd_sc_hd__decap_3
X_6480_ _6544_/A VGND VGND VPWR VPWR _6480_/Y sky130_fd_sc_hd__inv_2
X_3692_ _6715_/Q _3760_/B1 _3767_/B1 _6893_/Q _3691_/X VGND VGND VPWR VPWR _3692_/X
+ sky130_fd_sc_hd__a221o_2
XFILLER_9_573 VGND VGND VPWR VPWR sky130_fd_sc_hd__decap_3
XTAP_TAPCELL_ROW_76_1208 VGND VPWR sky130_fd_sc_hd__tapvpwrvgnd_1
XFILLER_114_622 VGND VGND VPWR VPWR sky130_fd_sc_hd__decap_3
X_5362_ _3378_/A _5646_/A _5362_/C VGND VGND VPWR VPWR _5429_/S sky130_fd_sc_hd__and3b_2
XFILLER_99_311 VGND VGND VPWR VPWR sky130_fd_sc_hd__decap_3
X_7101_ _7322_/CLK _7101_/D _6381_/Y VGND VGND VPWR VPWR _7101_/Q sky130_fd_sc_hd__dfrtp_2
X_4313_ _4376_/A _4364_/A _4364_/B _4313_/D VGND VGND VPWR VPWR _4315_/A sky130_fd_sc_hd__or4_4
XFILLER_114_666 VGND VGND VPWR VPWR sky130_fd_sc_hd__decap_3
XFILLER_59_208 VGND VGND VPWR VPWR sky130_fd_sc_hd__decap_3
XFILLER_59_219 VGND VGND VPWR VPWR sky130_fd_sc_hd__decap_3
X_7032_ _7350_/CLK _7032_/D _6312_/Y VGND VGND VPWR VPWR _7032_/Q sky130_fd_sc_hd__dfrtp_2
XFILLER_101_316 VGND VGND VPWR VPWR sky130_fd_sc_hd__decap_3
XFILLER_114_699 VGND VGND VPWR VPWR sky130_fd_sc_hd__fill_1
X_4244_ _7293_/Q _4244_/B VGND VGND VPWR VPWR _4244_/X sky130_fd_sc_hd__and2_2
XFILLER_101_349 VGND VGND VPWR VPWR sky130_fd_sc_hd__decap_3
X_4175_ _7328_/Q _3975_/S _4248_/A _4174_/X VGND VGND VPWR VPWR _4175_/X sky130_fd_sc_hd__a211o_2
XFILLER_27_116 VGND VGND VPWR VPWR sky130_fd_sc_hd__decap_3
XFILLER_28_628 VGND VGND VPWR VPWR sky130_fd_sc_hd__decap_3
XFILLER_67_274 VGND VGND VPWR VPWR sky130_fd_sc_hd__decap_3
XFILLER_82_200 VGND VGND VPWR VPWR sky130_fd_sc_hd__decap_3
XFILLER_83_712 VGND VGND VPWR VPWR sky130_fd_sc_hd__fill_2
XFILLER_95_594 VGND VGND VPWR VPWR sky130_fd_sc_hd__decap_3
XFILLER_27_149 VGND VGND VPWR VPWR sky130_fd_sc_hd__decap_3
XFILLER_55_447 VGND VGND VPWR VPWR sky130_fd_sc_hd__fill_1
XFILLER_82_222 VGND VGND VPWR VPWR sky130_fd_sc_hd__decap_3
XTAP_TAPCELL_ROW_87_1348 VGND VPWR sky130_fd_sc_hd__tapvpwrvgnd_1
XFILLER_36_672 VGND VGND VPWR VPWR sky130_fd_sc_hd__decap_3
XFILLER_43_609 VGND VGND VPWR VPWR sky130_fd_sc_hd__decap_3
XFILLER_23_300 VGND VGND VPWR VPWR sky130_fd_sc_hd__decap_3
XFILLER_35_160 VGND VGND VPWR VPWR sky130_fd_sc_hd__decap_3
XFILLER_51_620 VGND VGND VPWR VPWR sky130_fd_sc_hd__decap_3
XFILLER_35_193 VGND VGND VPWR VPWR sky130_fd_sc_hd__decap_3
XFILLER_50_141 VGND VGND VPWR VPWR sky130_fd_sc_hd__decap_3
XFILLER_51_653 VGND VGND VPWR VPWR sky130_fd_sc_hd__decap_3
Xplace491 _4467_/Y VGND VGND VPWR VPWR _5595_/B sky130_fd_sc_hd__buf_2
Xplace480 _4471_/S VGND VGND VPWR VPWR _3996_/S sky130_fd_sc_hd__buf_2
X_6816_ clkload3/A _6816_/D VGND VGND VPWR VPWR _6816_/Q sky130_fd_sc_hd__dfxtp_2
XFILLER_50_185 VGND VGND VPWR VPWR sky130_fd_sc_hd__decap_3
XFILLER_51_697 VGND VGND VPWR VPWR sky130_fd_sc_hd__decap_3
X_6747_ _6906_/CLK _6747_/D VGND VGND VPWR VPWR _6747_/Q sky130_fd_sc_hd__dfxtp_2
XFILLER_109_405 VGND VGND VPWR VPWR sky130_fd_sc_hd__fill_2
XTAP_TAPCELL_ROW_21_523 VGND VPWR sky130_fd_sc_hd__tapvpwrvgnd_1
X_6678_ _6678_/A VGND VGND VPWR VPWR _6678_/Y sky130_fd_sc_hd__inv_2
XFILLER_109_449 VGND VGND VPWR VPWR sky130_fd_sc_hd__decap_3
XTAP_TAPCELL_ROW_98_1488 VGND VPWR sky130_fd_sc_hd__tapvpwrvgnd_1
XTAP_TAPCELL_ROW_98_1477 VGND VPWR sky130_fd_sc_hd__tapvpwrvgnd_1
XFILLER_105_600 VGND VGND VPWR VPWR sky130_fd_sc_hd__decap_3
XFILLER_105_644 VGND VGND VPWR VPWR sky130_fd_sc_hd__decap_3
XFILLER_104_165 VGND VGND VPWR VPWR sky130_fd_sc_hd__decap_3
XFILLER_105_688 VGND VGND VPWR VPWR sky130_fd_sc_hd__decap_3
XFILLER_78_517 VGND VGND VPWR VPWR sky130_fd_sc_hd__decap_3
XFILLER_116_53 VGND VGND VPWR VPWR sky130_fd_sc_hd__decap_3
XFILLER_78_539 VGND VGND VPWR VPWR sky130_fd_sc_hd__decap_3
XFILLER_116_97 VGND VGND VPWR VPWR sky130_fd_sc_hd__decap_3
XFILLER_58_230 VGND VGND VPWR VPWR sky130_fd_sc_hd__decap_3
XFILLER_76_35 VGND VGND VPWR VPWR sky130_fd_sc_hd__decap_3
XFILLER_19_617 VGND VGND VPWR VPWR sky130_fd_sc_hd__decap_3
XFILLER_74_701 VGND VGND VPWR VPWR sky130_fd_sc_hd__decap_3
XFILLER_86_583 VGND VGND VPWR VPWR sky130_fd_sc_hd__decap_3
XFILLER_100_393 VGND VGND VPWR VPWR sky130_fd_sc_hd__decap_3
XFILLER_46_447 VGND VGND VPWR VPWR sky130_fd_sc_hd__decap_3
XTAP_TAPCELL_ROW_29_623 VGND VPWR sky130_fd_sc_hd__tapvpwrvgnd_1
XPHY_EDGE_ROW_85_Left_205 VGND VGND VPWR VPWR sky130_fd_sc_hd__decap_3
XFILLER_27_650 VGND VGND VPWR VPWR sky130_fd_sc_hd__decap_3
XTAP_TAPCELL_ROW_57_976 VGND VPWR sky130_fd_sc_hd__tapvpwrvgnd_1
XTAP_TAPCELL_ROW_57_965 VGND VPWR sky130_fd_sc_hd__tapvpwrvgnd_1
XTAP_TAPCELL_ROW_1_270 VGND VPWR sky130_fd_sc_hd__tapvpwrvgnd_1
XFILLER_27_694 VGND VGND VPWR VPWR sky130_fd_sc_hd__decap_3
XTAP_TAPCELL_ROW_107_1595 VGND VPWR sky130_fd_sc_hd__tapvpwrvgnd_1
XFILLER_14_355 VGND VGND VPWR VPWR sky130_fd_sc_hd__decap_3
XFILLER_26_193 VGND VGND VPWR VPWR sky130_fd_sc_hd__decap_3
XFILLER_42_642 VGND VGND VPWR VPWR sky130_fd_sc_hd__fill_2
XFILLER_42_675 VGND VGND VPWR VPWR sky130_fd_sc_hd__decap_3
XTAP_TAPCELL_ROW_60_1009 VGND VPWR sky130_fd_sc_hd__tapvpwrvgnd_1
XFILLER_10_572 VGND VGND VPWR VPWR sky130_fd_sc_hd__decap_3
XPHY_EDGE_ROW_94_Left_214 VGND VGND VPWR VPWR sky130_fd_sc_hd__decap_3
XFILLER_41_93 VGND VGND VPWR VPWR sky130_fd_sc_hd__decap_3
XFILLER_6_554 VGND VGND VPWR VPWR sky130_fd_sc_hd__decap_3
XFILLER_108_460 VGND VGND VPWR VPWR sky130_fd_sc_hd__decap_3
XFILLER_6_587 VGND VGND VPWR VPWR sky130_fd_sc_hd__fill_1
XFILLER_6_598 VGND VGND VPWR VPWR sky130_fd_sc_hd__decap_3
XFILLER_111_603 VGND VGND VPWR VPWR sky130_fd_sc_hd__decap_3
XFILLER_96_303 VGND VGND VPWR VPWR sky130_fd_sc_hd__decap_3
XTAP_TAPCELL_ROW_9_370 VGND VPWR sky130_fd_sc_hd__tapvpwrvgnd_1
XFILLER_111_647 VGND VGND VPWR VPWR sky130_fd_sc_hd__decap_3
XTAP_TAPCELL_ROW_71_1149 VGND VPWR sky130_fd_sc_hd__tapvpwrvgnd_1
XFILLER_110_124 VGND VGND VPWR VPWR sky130_fd_sc_hd__decap_3
XFILLER_110_157 VGND VGND VPWR VPWR sky130_fd_sc_hd__decap_3
XFILLER_1_281 VGND VGND VPWR VPWR sky130_fd_sc_hd__decap_3
XFILLER_2_65 VGND VGND VPWR VPWR sky130_fd_sc_hd__decap_3
XFILLER_49_252 VGND VGND VPWR VPWR sky130_fd_sc_hd__decap_3
XFILLER_49_263 VGND VGND VPWR VPWR sky130_fd_sc_hd__decap_3
XFILLER_65_712 VGND VGND VPWR VPWR sky130_fd_sc_hd__fill_2
XFILLER_77_572 VGND VGND VPWR VPWR sky130_fd_sc_hd__fill_1
XFILLER_37_447 VGND VGND VPWR VPWR sky130_fd_sc_hd__fill_1
XFILLER_49_296 VGND VGND VPWR VPWR sky130_fd_sc_hd__decap_3
XFILLER_64_222 VGND VGND VPWR VPWR sky130_fd_sc_hd__decap_3
XFILLER_18_672 VGND VGND VPWR VPWR sky130_fd_sc_hd__decap_3
XFILLER_37_469 VGND VGND VPWR VPWR sky130_fd_sc_hd__decap_3
XFILLER_64_277 VGND VGND VPWR VPWR sky130_fd_sc_hd__decap_3
XFILLER_80_704 VGND VGND VPWR VPWR sky130_fd_sc_hd__decap_3
XFILLER_17_160 VGND VGND VPWR VPWR sky130_fd_sc_hd__decap_3
XFILLER_33_620 VGND VGND VPWR VPWR sky130_fd_sc_hd__decap_3
XFILLER_52_439 VGND VGND VPWR VPWR sky130_fd_sc_hd__fill_1
X_4931_ _4931_/A _4931_/B VGND VGND VPWR VPWR _6996_/D sky130_fd_sc_hd__nor2_2
XFILLER_32_141 VGND VGND VPWR VPWR sky130_fd_sc_hd__decap_3
XFILLER_33_653 VGND VGND VPWR VPWR sky130_fd_sc_hd__decap_3
XFILLER_60_450 VGND VGND VPWR VPWR sky130_fd_sc_hd__decap_3
X_4862_ _4825_/B _4862_/B VGND VGND VPWR VPWR _7000_/D sky130_fd_sc_hd__and2b_2
XFILLER_20_303 VGND VGND VPWR VPWR sky130_fd_sc_hd__fill_1
XFILLER_32_163 VGND VGND VPWR VPWR sky130_fd_sc_hd__decap_3
XFILLER_33_697 VGND VGND VPWR VPWR sky130_fd_sc_hd__decap_3
X_6601_ _6631_/A VGND VGND VPWR VPWR _6601_/Y sky130_fd_sc_hd__inv_2
X_3813_ _3802_/X _3812_/X _3991_/A VGND VGND VPWR VPWR _3813_/Y sky130_fd_sc_hd__o21ai_2
XTAP_TAPCELL_ROW_82_1289 VGND VPWR sky130_fd_sc_hd__tapvpwrvgnd_1
XTAP_TAPCELL_ROW_82_1278 VGND VPWR sky130_fd_sc_hd__tapvpwrvgnd_1
X_4793_ _4793_/A0 _4792_/X _4865_/S VGND VGND VPWR VPWR _7274_/D sky130_fd_sc_hd__mux2_2
X_6532_ _6627_/A VGND VGND VPWR VPWR _6532_/Y sky130_fd_sc_hd__inv_2
X_3744_ _6728_/Q _3892_/A2 _3890_/B1 _6973_/Q VGND VGND VPWR VPWR _3744_/X sky130_fd_sc_hd__a22o_2
X_6463_ _6463_/A VGND VGND VPWR VPWR _6463_/Y sky130_fd_sc_hd__inv_2
XFILLER_106_419 VGND VGND VPWR VPWR sky130_fd_sc_hd__fill_1
X_6394_ _6653_/A VGND VGND VPWR VPWR _6394_/Y sky130_fd_sc_hd__inv_2
XFILLER_114_452 VGND VGND VPWR VPWR sky130_fd_sc_hd__decap_3
XFILLER_99_163 VGND VGND VPWR VPWR sky130_fd_sc_hd__decap_3
XFILLER_101_113 VGND VGND VPWR VPWR sky130_fd_sc_hd__decap_3
XFILLER_102_625 VGND VGND VPWR VPWR sky130_fd_sc_hd__decap_3
X_5276_ _5276_/A0 _5094_/X _5292_/S VGND VGND VPWR VPWR _7192_/D sky130_fd_sc_hd__mux2_2
XFILLER_99_185 VGND VGND VPWR VPWR sky130_fd_sc_hd__decap_3
XFILLER_101_146 VGND VGND VPWR VPWR sky130_fd_sc_hd__decap_3
XFILLER_102_669 VGND VGND VPWR VPWR sky130_fd_sc_hd__decap_3
XFILLER_87_358 VGND VGND VPWR VPWR sky130_fd_sc_hd__decap_3
X_7015_ _7344_/CLK _7015_/D _6295_/Y VGND VGND VPWR VPWR _7015_/Q sky130_fd_sc_hd__dfrtp_2
X_4227_ _7355_/Q _4416_/A2 _4352_/B1 _7163_/Q VGND VGND VPWR VPWR _4227_/X sky130_fd_sc_hd__a22o_2
XFILLER_56_701 VGND VGND VPWR VPWR sky130_fd_sc_hd__decap_3
XFILLER_28_436 VGND VGND VPWR VPWR sky130_fd_sc_hd__decap_3
XFILLER_46_38 VGND VGND VPWR VPWR sky130_fd_sc_hd__decap_3
XFILLER_83_520 VGND VGND VPWR VPWR sky130_fd_sc_hd__decap_3
XFILLER_95_380 VGND VGND VPWR VPWR sky130_fd_sc_hd__decap_3
X_4158_ _4158_/A _4158_/B VGND VGND VPWR VPWR _4920_/A sky130_fd_sc_hd__nand2_2
XFILLER_102_11 VGND VGND VPWR VPWR sky130_fd_sc_hd__fill_2
XFILLER_15_108 VGND VGND VPWR VPWR sky130_fd_sc_hd__decap_3
XFILLER_28_469 VGND VGND VPWR VPWR sky130_fd_sc_hd__decap_3
XFILLER_43_417 VGND VGND VPWR VPWR sky130_fd_sc_hd__decap_3
XFILLER_55_255 VGND VGND VPWR VPWR sky130_fd_sc_hd__decap_3
X_4089_ _7206_/Q _3966_/S _4419_/B1 _7398_/Q VGND VGND VPWR VPWR _4089_/X sky130_fd_sc_hd__a22o_2
XFILLER_102_55 VGND VGND VPWR VPWR sky130_fd_sc_hd__decap_3
XFILLER_43_428 VGND VGND VPWR VPWR sky130_fd_sc_hd__decap_3
XFILLER_70_203 VGND VGND VPWR VPWR sky130_fd_sc_hd__decap_3
XFILLER_83_597 VGND VGND VPWR VPWR sky130_fd_sc_hd__fill_1
XTAP_TAPCELL_ROW_54_935 VGND VPWR sky130_fd_sc_hd__tapvpwrvgnd_1
XFILLER_102_77 VGND VGND VPWR VPWR sky130_fd_sc_hd__fill_1
XFILLER_102_88 VGND VGND VPWR VPWR sky130_fd_sc_hd__decap_3
XFILLER_24_631 VGND VGND VPWR VPWR sky130_fd_sc_hd__decap_3
XFILLER_62_26 VGND VGND VPWR VPWR sky130_fd_sc_hd__fill_2
XFILLER_24_675 VGND VGND VPWR VPWR sky130_fd_sc_hd__decap_3
XTAP_TAPCELL_ROW_34_681 VGND VPWR sky130_fd_sc_hd__tapvpwrvgnd_1
XFILLER_109_246 VGND VGND VPWR VPWR sky130_fd_sc_hd__decap_3
XFILLER_3_502 VGND VGND VPWR VPWR sky130_fd_sc_hd__fill_2
XFILLER_3_535 VGND VGND VPWR VPWR sky130_fd_sc_hd__decap_3
XFILLER_105_452 VGND VGND VPWR VPWR sky130_fd_sc_hd__decap_3
XFILLER_117_290 VGND VGND VPWR VPWR sky130_fd_sc_hd__decap_3
XFILLER_11_96 VGND VGND VPWR VPWR sky130_fd_sc_hd__decap_3
XFILLER_2_3 VGND VGND VPWR VPWR sky130_fd_sc_hd__fill_1
XFILLER_3_579 VGND VGND VPWR VPWR sky130_fd_sc_hd__decap_3
XFILLER_87_34 VGND VGND VPWR VPWR sky130_fd_sc_hd__decap_3
XFILLER_78_303 VGND VGND VPWR VPWR sky130_fd_sc_hd__decap_3
XFILLER_87_78 VGND VGND VPWR VPWR sky130_fd_sc_hd__decap_3
XFILLER_46_200 VGND VGND VPWR VPWR sky130_fd_sc_hd__decap_3
XFILLER_47_712 VGND VGND VPWR VPWR sky130_fd_sc_hd__fill_2
XFILLER_93_317 VGND VGND VPWR VPWR sky130_fd_sc_hd__decap_3
XFILLER_101_691 VGND VGND VPWR VPWR sky130_fd_sc_hd__decap_3
XFILLER_19_436 VGND VGND VPWR VPWR sky130_fd_sc_hd__decap_3
XFILLER_74_531 VGND VGND VPWR VPWR sky130_fd_sc_hd__fill_1
XTAP_TAPCELL_ROW_109_1624 VGND VPWR sky130_fd_sc_hd__tapvpwrvgnd_1
XFILLER_100_190 VGND VGND VPWR VPWR sky130_fd_sc_hd__decap_3
XFILLER_19_458 VGND VGND VPWR VPWR sky130_fd_sc_hd__fill_2
XFILLER_62_704 VGND VGND VPWR VPWR sky130_fd_sc_hd__decap_3
XFILLER_74_564 VGND VGND VPWR VPWR sky130_fd_sc_hd__decap_3
XFILLER_15_620 VGND VGND VPWR VPWR sky130_fd_sc_hd__decap_3
XFILLER_34_417 VGND VGND VPWR VPWR sky130_fd_sc_hd__decap_3
XFILLER_46_277 VGND VGND VPWR VPWR sky130_fd_sc_hd__decap_3
XFILLER_74_586 VGND VGND VPWR VPWR sky130_fd_sc_hd__fill_2
XFILLER_15_653 VGND VGND VPWR VPWR sky130_fd_sc_hd__decap_3
XFILLER_61_236 VGND VGND VPWR VPWR sky130_fd_sc_hd__decap_3
XFILLER_14_141 VGND VGND VPWR VPWR sky130_fd_sc_hd__decap_3
XFILLER_15_697 VGND VGND VPWR VPWR sky130_fd_sc_hd__decap_3
XFILLER_30_601 VGND VGND VPWR VPWR sky130_fd_sc_hd__decap_3
XFILLER_42_450 VGND VGND VPWR VPWR sky130_fd_sc_hd__fill_1
XFILLER_42_472 VGND VGND VPWR VPWR sky130_fd_sc_hd__decap_3
XFILLER_30_634 VGND VGND VPWR VPWR sky130_fd_sc_hd__decap_3
XFILLER_30_645 VGND VGND VPWR VPWR sky130_fd_sc_hd__decap_3
XFILLER_30_678 VGND VGND VPWR VPWR sky130_fd_sc_hd__decap_3
XFILLER_52_70 VGND VGND VPWR VPWR sky130_fd_sc_hd__decap_3
XFILLER_10_380 VGND VGND VPWR VPWR sky130_fd_sc_hd__decap_3
Xhold808 _6918_/Q VGND VGND VPWR VPWR _6918_/D sky130_fd_sc_hd__dlygate4sd3_1
Xhold819 _6915_/Q VGND VGND VPWR VPWR _6915_/D sky130_fd_sc_hd__dlygate4sd3_1
XFILLER_115_249 VGND VGND VPWR VPWR sky130_fd_sc_hd__decap_3
X_3460_ _7313_/Q _3987_/S _4285_/B1 _7345_/Q _3556_/A VGND VGND VPWR VPWR _3460_/X
+ sky130_fd_sc_hd__a221o_2
X_3391_ _7251_/Q _4599_/S _3390_/X VGND VGND VPWR VPWR _3589_/A sky130_fd_sc_hd__a21oi_2
XFILLER_69_314 VGND VGND VPWR VPWR sky130_fd_sc_hd__decap_3
XFILLER_69_325 VGND VGND VPWR VPWR sky130_fd_sc_hd__fill_2
XFILLER_97_623 VGND VGND VPWR VPWR sky130_fd_sc_hd__decap_3
X_5130_ _5130_/A _5670_/B _5130_/C VGND VGND VPWR VPWR _6982_/D sky130_fd_sc_hd__nor3_2
XFILLER_111_444 VGND VGND VPWR VPWR sky130_fd_sc_hd__decap_3
XFILLER_69_358 VGND VGND VPWR VPWR sky130_fd_sc_hd__decap_3
XFILLER_96_122 VGND VGND VPWR VPWR sky130_fd_sc_hd__decap_3
XFILLER_96_144 VGND VGND VPWR VPWR sky130_fd_sc_hd__decap_3
XFILLER_97_656 VGND VGND VPWR VPWR sky130_fd_sc_hd__decap_3
X_5061_ _6988_/D _5060_/X _5156_/S VGND VGND VPWR VPWR _5061_/X sky130_fd_sc_hd__mux2_2
XFILLER_38_701 VGND VGND VPWR VPWR sky130_fd_sc_hd__decap_3
XFILLER_96_177 VGND VGND VPWR VPWR sky130_fd_sc_hd__decap_3
XFILLER_37_200 VGND VGND VPWR VPWR sky130_fd_sc_hd__decap_3
XFILLER_37_233 VGND VGND VPWR VPWR sky130_fd_sc_hd__decap_3
XFILLER_65_520 VGND VGND VPWR VPWR sky130_fd_sc_hd__decap_3
XFILLER_37_266 VGND VGND VPWR VPWR sky130_fd_sc_hd__decap_3
XFILLER_80_501 VGND VGND VPWR VPWR sky130_fd_sc_hd__decap_3
XTAP_TAPCELL_ROW_84_1307 VGND VPWR sky130_fd_sc_hd__tapvpwrvgnd_1
XFILLER_92_394 VGND VGND VPWR VPWR sky130_fd_sc_hd__decap_3
XFILLER_52_236 VGND VGND VPWR VPWR sky130_fd_sc_hd__decap_3
X_4914_ _4914_/A0 _4913_/X _4914_/S VGND VGND VPWR VPWR _7267_/D sky130_fd_sc_hd__mux2_2
XFILLER_21_612 VGND VGND VPWR VPWR sky130_fd_sc_hd__decap_3
XFILLER_33_461 VGND VGND VPWR VPWR sky130_fd_sc_hd__decap_3
XFILLER_80_589 VGND VGND VPWR VPWR sky130_fd_sc_hd__decap_3
XFILLER_21_623 VGND VGND VPWR VPWR sky130_fd_sc_hd__decap_3
XFILLER_21_656 VGND VGND VPWR VPWR sky130_fd_sc_hd__decap_3
XFILLER_32_29 VGND VGND VPWR VPWR sky130_fd_sc_hd__decap_3
XFILLER_60_291 VGND VGND VPWR VPWR sky130_fd_sc_hd__decap_3
X_4845_ _4845_/A VGND VGND VPWR VPWR _4872_/A sky130_fd_sc_hd__inv_2
XFILLER_119_522 VGND VGND VPWR VPWR sky130_fd_sc_hd__decap_3
XFILLER_20_144 VGND VGND VPWR VPWR sky130_fd_sc_hd__decap_3
X_4776_ _7004_/Q _4804_/A VGND VGND VPWR VPWR _4777_/C sky130_fd_sc_hd__or2_2
XTAP_TAPCELL_ROW_31_651 VGND VPWR sky130_fd_sc_hd__tapvpwrvgnd_1
XTAP_TAPCELL_ROW_31_640 VGND VPWR sky130_fd_sc_hd__tapvpwrvgnd_1
XFILLER_119_533 VGND VGND VPWR VPWR sky130_fd_sc_hd__decap_3
X_6515_ _6645_/A VGND VGND VPWR VPWR _6515_/Y sky130_fd_sc_hd__inv_2
X_3727_ _3746_/B _3733_/C VGND VGND VPWR VPWR _3728_/B sky130_fd_sc_hd__nand2_2
XFILLER_107_706 VGND VGND VPWR VPWR sky130_fd_sc_hd__decap_3
X_6446_ _6641_/A VGND VGND VPWR VPWR _6446_/Y sky130_fd_sc_hd__inv_2
XTAP_TAPCELL_ROW_95_1447 VGND VPWR sky130_fd_sc_hd__tapvpwrvgnd_1
X_6377_ _6608_/A VGND VGND VPWR VPWR _6377_/Y sky130_fd_sc_hd__inv_2
X_3589_ _3589_/A _3589_/B VGND VGND VPWR VPWR _3590_/B sky130_fd_sc_hd__nor2_2
XFILLER_0_505 VGND VGND VPWR VPWR sky130_fd_sc_hd__decap_3
XFILLER_87_100 VGND VGND VPWR VPWR sky130_fd_sc_hd__decap_3
XFILLER_88_612 VGND VGND VPWR VPWR sky130_fd_sc_hd__decap_3
XFILLER_0_549 VGND VGND VPWR VPWR sky130_fd_sc_hd__decap_3
XFILLER_102_444 VGND VGND VPWR VPWR sky130_fd_sc_hd__decap_3
XFILLER_87_122 VGND VGND VPWR VPWR sky130_fd_sc_hd__decap_3
XFILLER_88_645 VGND VGND VPWR VPWR sky130_fd_sc_hd__decap_3
XFILLER_88_678 VGND VGND VPWR VPWR sky130_fd_sc_hd__decap_3
XFILLER_102_477 VGND VGND VPWR VPWR sky130_fd_sc_hd__decap_3
XFILLER_29_712 VGND VGND VPWR VPWR sky130_fd_sc_hd__fill_2
XFILLER_28_200 VGND VGND VPWR VPWR sky130_fd_sc_hd__decap_3
XFILLER_87_199 VGND VGND VPWR VPWR sky130_fd_sc_hd__decap_3
XFILLER_113_32 VGND VGND VPWR VPWR sky130_fd_sc_hd__decap_3
XFILLER_44_704 VGND VGND VPWR VPWR sky130_fd_sc_hd__decap_3
XFILLER_90_309 VGND VGND VPWR VPWR sky130_fd_sc_hd__decap_3
XTAP_TAPCELL_ROW_39_751 VGND VPWR sky130_fd_sc_hd__tapvpwrvgnd_1
XTAP_TAPCELL_ROW_39_740 VGND VPWR sky130_fd_sc_hd__tapvpwrvgnd_1
XFILLER_113_87 VGND VGND VPWR VPWR sky130_fd_sc_hd__decap_3
XFILLER_16_417 VGND VGND VPWR VPWR sky130_fd_sc_hd__decap_3
XFILLER_16_439 VGND VGND VPWR VPWR sky130_fd_sc_hd__decap_3
XFILLER_28_288 VGND VGND VPWR VPWR sky130_fd_sc_hd__decap_3
XFILLER_43_214 VGND VGND VPWR VPWR sky130_fd_sc_hd__decap_3
XFILLER_43_225 VGND VGND VPWR VPWR sky130_fd_sc_hd__decap_3
XFILLER_43_247 VGND VGND VPWR VPWR sky130_fd_sc_hd__decap_3
XFILLER_12_601 VGND VGND VPWR VPWR sky130_fd_sc_hd__decap_3
XTAP_TAPCELL_ROW_104_1554 VGND VPWR sky130_fd_sc_hd__tapvpwrvgnd_1
XFILLER_11_111 VGND VGND VPWR VPWR sky130_fd_sc_hd__fill_1
XFILLER_11_122 VGND VGND VPWR VPWR sky130_fd_sc_hd__decap_3
XFILLER_12_634 VGND VGND VPWR VPWR sky130_fd_sc_hd__decap_3
XFILLER_12_645 VGND VGND VPWR VPWR sky130_fd_sc_hd__decap_3
XFILLER_24_483 VGND VGND VPWR VPWR sky130_fd_sc_hd__decap_3
XFILLER_12_678 VGND VGND VPWR VPWR sky130_fd_sc_hd__decap_3
XFILLER_8_616 VGND VGND VPWR VPWR sky130_fd_sc_hd__decap_3
XFILLER_11_199 VGND VGND VPWR VPWR sky130_fd_sc_hd__decap_3
XFILLER_22_40 VGND VGND VPWR VPWR sky130_fd_sc_hd__decap_3
XFILLER_7_126 VGND VGND VPWR VPWR sky130_fd_sc_hd__decap_3
XFILLER_7_159 VGND VGND VPWR VPWR sky130_fd_sc_hd__decap_3
XTAP_TAPCELL_ROW_59_1000 VGND VPWR sky130_fd_sc_hd__tapvpwrvgnd_1
XFILLER_98_11 VGND VGND VPWR VPWR sky130_fd_sc_hd__fill_1
XFILLER_113_709 VGND VGND VPWR VPWR sky130_fd_sc_hd__decap_3
XFILLER_3_343 VGND VGND VPWR VPWR sky130_fd_sc_hd__decap_3
XFILLER_98_409 VGND VGND VPWR VPWR sky130_fd_sc_hd__decap_3
XFILLER_98_77 VGND VGND VPWR VPWR sky130_fd_sc_hd__decap_3
XFILLER_105_271 VGND VGND VPWR VPWR sky130_fd_sc_hd__decap_3
XFILLER_3_376 VGND VGND VPWR VPWR sky130_fd_sc_hd__decap_3
XFILLER_78_100 VGND VGND VPWR VPWR sky130_fd_sc_hd__decap_3
XFILLER_79_623 VGND VGND VPWR VPWR sky130_fd_sc_hd__decap_3
XTAP_TAPCELL_ROW_115_1694 VGND VPWR sky130_fd_sc_hd__tapvpwrvgnd_1
XFILLER_98_99 VGND VGND VPWR VPWR sky130_fd_sc_hd__decap_3
XFILLER_78_133 VGND VGND VPWR VPWR sky130_fd_sc_hd__decap_3
XFILLER_78_144 VGND VGND VPWR VPWR sky130_fd_sc_hd__decap_3
XFILLER_79_656 VGND VGND VPWR VPWR sky130_fd_sc_hd__decap_3
XFILLER_66_306 VGND VGND VPWR VPWR sky130_fd_sc_hd__fill_2
XFILLER_78_166 VGND VGND VPWR VPWR sky130_fd_sc_hd__decap_3
XFILLER_19_211 VGND VGND VPWR VPWR sky130_fd_sc_hd__decap_3
XFILLER_47_531 VGND VGND VPWR VPWR sky130_fd_sc_hd__decap_3
XFILLER_59_380 VGND VGND VPWR VPWR sky130_fd_sc_hd__decap_3
XFILLER_66_328 VGND VGND VPWR VPWR sky130_fd_sc_hd__decap_3
XFILLER_93_125 VGND VGND VPWR VPWR sky130_fd_sc_hd__decap_3
XFILLER_94_637 VGND VGND VPWR VPWR sky130_fd_sc_hd__decap_3
XFILLER_94_648 VGND VGND VPWR VPWR sky130_fd_sc_hd__decap_3
XFILLER_47_564 VGND VGND VPWR VPWR sky130_fd_sc_hd__fill_1
XFILLER_93_169 VGND VGND VPWR VPWR sky130_fd_sc_hd__decap_3
XFILLER_19_277 VGND VGND VPWR VPWR sky130_fd_sc_hd__decap_3
XFILLER_34_203 VGND VGND VPWR VPWR sky130_fd_sc_hd__decap_3
XFILLER_34_214 VGND VGND VPWR VPWR sky130_fd_sc_hd__decap_3
XFILLER_47_586 VGND VGND VPWR VPWR sky130_fd_sc_hd__fill_2
XFILLER_62_512 VGND VGND VPWR VPWR sky130_fd_sc_hd__fill_2
XFILLER_34_247 VGND VGND VPWR VPWR sky130_fd_sc_hd__decap_3
XFILLER_50_707 VGND VGND VPWR VPWR sky130_fd_sc_hd__decap_3
XFILLER_15_461 VGND VGND VPWR VPWR sky130_fd_sc_hd__decap_3
XFILLER_62_589 VGND VGND VPWR VPWR sky130_fd_sc_hd__decap_3
XTAP_TAPCELL_ROW_17_467 VGND VPWR sky130_fd_sc_hd__tapvpwrvgnd_1
X_4630_ _4627_/Y _4629_/Y _4372_/A VGND VGND VPWR VPWR _4630_/X sky130_fd_sc_hd__a21o_2
XFILLER_30_486 VGND VGND VPWR VPWR sky130_fd_sc_hd__decap_3
X_6300_ _6622_/A VGND VGND VPWR VPWR _6300_/Y sky130_fd_sc_hd__inv_2
X_4561_ _4561_/A _4577_/B VGND VGND VPWR VPWR _7300_/D sky130_fd_sc_hd__and2_2
XFILLER_116_536 VGND VGND VPWR VPWR sky130_fd_sc_hd__fill_2
XFILLER_116_547 VGND VGND VPWR VPWR sky130_fd_sc_hd__decap_3
XFILLER_7_671 VGND VGND VPWR VPWR sky130_fd_sc_hd__fill_1
XFILLER_7_682 VGND VGND VPWR VPWR sky130_fd_sc_hd__decap_3
X_7280_ _7344_/CLK _7280_/D _6560_/Y VGND VGND VPWR VPWR _7280_/Q sky130_fd_sc_hd__dfrtp_2
XFILLER_89_409 VGND VGND VPWR VPWR sky130_fd_sc_hd__decap_3
XFILLER_69_111 VGND VGND VPWR VPWR sky130_fd_sc_hd__fill_1
XFILLER_69_122 VGND VGND VPWR VPWR sky130_fd_sc_hd__decap_3
XFILLER_97_431 VGND VGND VPWR VPWR sky130_fd_sc_hd__decap_3
X_5113_ _5113_/A _5113_/B VGND VGND VPWR VPWR _5113_/Y sky130_fd_sc_hd__xnor2_2
XFILLER_69_155 VGND VGND VPWR VPWR sky130_fd_sc_hd__decap_3
XFILLER_84_103 VGND VGND VPWR VPWR sky130_fd_sc_hd__decap_3
XFILLER_85_626 VGND VGND VPWR VPWR sky130_fd_sc_hd__decap_3
XFILLER_97_486 VGND VGND VPWR VPWR sky130_fd_sc_hd__decap_3
Xhold1305 _7293_/Q VGND VGND VPWR VPWR _4575_/A sky130_fd_sc_hd__dlygate4sd3_1
Xhold1316 _7298_/Q VGND VGND VPWR VPWR _4565_/A sky130_fd_sc_hd__dlygate4sd3_1
XTAP_TAPCELL_ROW_90_1388 VGND VPWR sky130_fd_sc_hd__tapvpwrvgnd_1
XTAP_TAPCELL_ROW_90_1377 VGND VPWR sky130_fd_sc_hd__tapvpwrvgnd_1
XFILLER_111_274 VGND VGND VPWR VPWR sky130_fd_sc_hd__decap_3
XFILLER_111_296 VGND VGND VPWR VPWR sky130_fd_sc_hd__decap_3
XFILLER_84_136 VGND VGND VPWR VPWR sky130_fd_sc_hd__decap_3
XFILLER_85_659 VGND VGND VPWR VPWR sky130_fd_sc_hd__decap_3
X_5044_ _5044_/A _5044_/B VGND VGND VPWR VPWR _6988_/D sky130_fd_sc_hd__nor2_2
XFILLER_26_704 VGND VGND VPWR VPWR sky130_fd_sc_hd__decap_3
XFILLER_27_29 VGND VGND VPWR VPWR sky130_fd_sc_hd__fill_1
XFILLER_72_309 VGND VGND VPWR VPWR sky130_fd_sc_hd__decap_3
XFILLER_53_501 VGND VGND VPWR VPWR sky130_fd_sc_hd__decap_3
XTAP_TAPCELL_ROW_36_710 VGND VPWR sky130_fd_sc_hd__tapvpwrvgnd_1
XFILLER_25_225 VGND VGND VPWR VPWR sky130_fd_sc_hd__decap_3
XFILLER_92_180 VGND VGND VPWR VPWR sky130_fd_sc_hd__decap_3
X_6995_ _7400_/CLK _6995_/D _6275_/Y VGND VGND VPWR VPWR _6995_/Q sky130_fd_sc_hd__dfrtp_2
XFILLER_40_206 VGND VGND VPWR VPWR sky130_fd_sc_hd__decap_3
XFILLER_43_28 VGND VGND VPWR VPWR sky130_fd_sc_hd__fill_1
XFILLER_80_386 VGND VGND VPWR VPWR sky130_fd_sc_hd__decap_3
XFILLER_21_431 VGND VGND VPWR VPWR sky130_fd_sc_hd__decap_3
XFILLER_40_239 VGND VGND VPWR VPWR sky130_fd_sc_hd__decap_3
X_4828_ _4970_/A1 _4810_/B _4827_/A _5033_/B2 VGND VGND VPWR VPWR _4828_/X sky130_fd_sc_hd__a22o_2
XFILLER_107_503 VGND VGND VPWR VPWR sky130_fd_sc_hd__fill_1
X_4759_ _4759_/A _4777_/B VGND VGND VPWR VPWR _4760_/B sky130_fd_sc_hd__xnor2_2
XFILLER_107_536 VGND VGND VPWR VPWR sky130_fd_sc_hd__decap_3
XFILLER_104_6 VGND VGND VPWR VPWR sky130_fd_sc_hd__fill_1
XFILLER_107_569 VGND VGND VPWR VPWR sky130_fd_sc_hd__decap_3
XFILLER_108_21 VGND VGND VPWR VPWR sky130_fd_sc_hd__decap_3
XFILLER_108_32 VGND VGND VPWR VPWR sky130_fd_sc_hd__decap_3
X_6429_ _6652_/A VGND VGND VPWR VPWR _6429_/Y sky130_fd_sc_hd__inv_2
XFILLER_108_65 VGND VGND VPWR VPWR sky130_fd_sc_hd__decap_3
XFILLER_88_442 VGND VGND VPWR VPWR sky130_fd_sc_hd__decap_3
XFILLER_0_357 VGND VGND VPWR VPWR sky130_fd_sc_hd__decap_3
XFILLER_0_368 VGND VGND VPWR VPWR sky130_fd_sc_hd__fill_2
XFILLER_48_306 VGND VGND VPWR VPWR sky130_fd_sc_hd__fill_2
XFILLER_75_103 VGND VGND VPWR VPWR sky130_fd_sc_hd__decap_3
XFILLER_76_615 VGND VGND VPWR VPWR sky130_fd_sc_hd__decap_3
XFILLER_88_453 VGND VGND VPWR VPWR sky130_fd_sc_hd__fill_1
XFILLER_88_475 VGND VGND VPWR VPWR sky130_fd_sc_hd__fill_1
XFILLER_88_486 VGND VGND VPWR VPWR sky130_fd_sc_hd__decap_3
XFILLER_102_274 VGND VGND VPWR VPWR sky130_fd_sc_hd__decap_3
XFILLER_102_296 VGND VGND VPWR VPWR sky130_fd_sc_hd__decap_3
XFILLER_76_648 VGND VGND VPWR VPWR sky130_fd_sc_hd__decap_3
XFILLER_29_564 VGND VGND VPWR VPWR sky130_fd_sc_hd__decap_3
XFILLER_56_350 VGND VGND VPWR VPWR sky130_fd_sc_hd__decap_3
XFILLER_75_147 VGND VGND VPWR VPWR sky130_fd_sc_hd__decap_3
XFILLER_75_169 VGND VGND VPWR VPWR sky130_fd_sc_hd__decap_3
XFILLER_91_607 VGND VGND VPWR VPWR sky130_fd_sc_hd__decap_3
XFILLER_16_203 VGND VGND VPWR VPWR sky130_fd_sc_hd__decap_3
XFILLER_29_597 VGND VGND VPWR VPWR sky130_fd_sc_hd__decap_3
XFILLER_84_57 VGND VGND VPWR VPWR sky130_fd_sc_hd__decap_3
XFILLER_84_681 VGND VGND VPWR VPWR sky130_fd_sc_hd__decap_3
XFILLER_91_629 VGND VGND VPWR VPWR sky130_fd_sc_hd__decap_3
XFILLER_16_225 VGND VGND VPWR VPWR sky130_fd_sc_hd__decap_3
XFILLER_16_236 VGND VGND VPWR VPWR sky130_fd_sc_hd__decap_3
XFILLER_17_51 VGND VGND VPWR VPWR sky130_fd_sc_hd__decap_3
XFILLER_32_707 VGND VGND VPWR VPWR sky130_fd_sc_hd__decap_3
XFILLER_44_556 VGND VGND VPWR VPWR sky130_fd_sc_hd__decap_3
XFILLER_17_84 VGND VGND VPWR VPWR sky130_fd_sc_hd__decap_3
XFILLER_31_217 VGND VGND VPWR VPWR sky130_fd_sc_hd__decap_3
XFILLER_44_589 VGND VGND VPWR VPWR sky130_fd_sc_hd__decap_3
XFILLER_31_228 VGND VGND VPWR VPWR sky130_fd_sc_hd__decap_3
XTAP_TAPCELL_ROW_65_1070 VGND VPWR sky130_fd_sc_hd__tapvpwrvgnd_1
XTAP_TAPCELL_ROW_14_437 VGND VPWR sky130_fd_sc_hd__tapvpwrvgnd_1
XFILLER_12_464 VGND VGND VPWR VPWR sky130_fd_sc_hd__decap_3
XTAP_TAPCELL_ROW_42_779 VGND VPWR sky130_fd_sc_hd__tapvpwrvgnd_1
XFILLER_12_486 VGND VGND VPWR VPWR sky130_fd_sc_hd__decap_3
XTAP_TAPCELL_ROW_117_1723 VGND VPWR sky130_fd_sc_hd__tapvpwrvgnd_1
XFILLER_4_641 VGND VGND VPWR VPWR sky130_fd_sc_hd__decap_3
XFILLER_3_162 VGND VGND VPWR VPWR sky130_fd_sc_hd__fill_2
XFILLER_4_663 VGND VGND VPWR VPWR sky130_fd_sc_hd__decap_3
XFILLER_98_228 VGND VGND VPWR VPWR sky130_fd_sc_hd__decap_3
XFILLER_4_696 VGND VGND VPWR VPWR sky130_fd_sc_hd__decap_3
XFILLER_67_615 VGND VGND VPWR VPWR sky130_fd_sc_hd__fill_1
XFILLER_67_626 VGND VGND VPWR VPWR sky130_fd_sc_hd__decap_3
XFILLER_94_401 VGND VGND VPWR VPWR sky130_fd_sc_hd__decap_3
XFILLER_67_659 VGND VGND VPWR VPWR sky130_fd_sc_hd__decap_3
XFILLER_54_309 VGND VGND VPWR VPWR sky130_fd_sc_hd__decap_3
XFILLER_66_147 VGND VGND VPWR VPWR sky130_fd_sc_hd__fill_1
XFILLER_66_158 VGND VGND VPWR VPWR sky130_fd_sc_hd__decap_3
XFILLER_81_128 VGND VGND VPWR VPWR sky130_fd_sc_hd__decap_3
XFILLER_62_320 VGND VGND VPWR VPWR sky130_fd_sc_hd__decap_3
XFILLER_74_180 VGND VGND VPWR VPWR sky130_fd_sc_hd__decap_3
XFILLER_90_640 VGND VGND VPWR VPWR sky130_fd_sc_hd__decap_3
XFILLER_90_651 VGND VGND VPWR VPWR sky130_fd_sc_hd__decap_3
XFILLER_50_504 VGND VGND VPWR VPWR sky130_fd_sc_hd__decap_3
XFILLER_62_375 VGND VGND VPWR VPWR sky130_fd_sc_hd__fill_1
XFILLER_90_684 VGND VGND VPWR VPWR sky130_fd_sc_hd__decap_3
X_6780_ clkload8/A _6780_/D VGND VGND VPWR VPWR _6780_/Q sky130_fd_sc_hd__dfxtp_2
X_3992_ _5156_/S _5587_/B VGND VGND VPWR VPWR _3992_/Y sky130_fd_sc_hd__nand2_2
XFILLER_22_239 VGND VGND VPWR VPWR sky130_fd_sc_hd__decap_3
X_5731_ _7371_/Q _5731_/A1 _5735_/S VGND VGND VPWR VPWR _6715_/D sky130_fd_sc_hd__mux2_2
XFILLER_30_250 VGND VGND VPWR VPWR sky130_fd_sc_hd__fill_2
XFILLER_30_272 VGND VGND VPWR VPWR sky130_fd_sc_hd__decap_3
X_5662_ _5662_/A _5662_/B _5662_/C _5661_/X VGND VGND VPWR VPWR _5663_/D sky130_fd_sc_hd__or4b_4
X_7401_ _7406_/CLK _7401_/D _6681_/Y VGND VGND VPWR VPWR _7401_/Q sky130_fd_sc_hd__dfrtp_2
X_5593_ _5593_/A _5595_/B VGND VGND VPWR VPWR _7031_/D sky130_fd_sc_hd__or2_2
X_4613_ _4614_/B _4613_/B _5113_/A VGND VGND VPWR VPWR _4617_/B sky130_fd_sc_hd__and3_2
X_7332_ _7333_/CLK _7332_/D _6612_/Y VGND VGND VPWR VPWR _7332_/Q sky130_fd_sc_hd__dfrtp_2
X_4544_ _7308_/Q _4563_/B VGND VGND VPWR VPWR _7308_/D sky130_fd_sc_hd__and2_2
XFILLER_7_490 VGND VGND VPWR VPWR sky130_fd_sc_hd__decap_3
X_7263_ _7362_/CLK _7263_/D _6543_/Y VGND VGND VPWR VPWR _7263_/Q sky130_fd_sc_hd__dfrtp_2
XTAP_TAPCELL_ROW_92_1406 VGND VPWR sky130_fd_sc_hd__tapvpwrvgnd_1
XFILLER_104_528 VGND VGND VPWR VPWR sky130_fd_sc_hd__decap_3
XFILLER_116_388 VGND VGND VPWR VPWR sky130_fd_sc_hd__fill_2
XFILLER_89_228 VGND VGND VPWR VPWR sky130_fd_sc_hd__decap_3
X_7194_ _7357_/CLK _7194_/D _6474_/Y VGND VGND VPWR VPWR _7194_/Q sky130_fd_sc_hd__dfrtp_2
X_3426_ _3589_/A _3591_/A _3589_/B _3590_/C VGND VGND VPWR VPWR _3427_/B sky130_fd_sc_hd__or4_4
XFILLER_100_701 VGND VGND VPWR VPWR sky130_fd_sc_hd__decap_3
X_3357_ _4537_/B VGND VGND VPWR VPWR _3449_/A sky130_fd_sc_hd__inv_6
XFILLER_112_583 VGND VGND VPWR VPWR sky130_fd_sc_hd__decap_3
XFILLER_58_637 VGND VGND VPWR VPWR sky130_fd_sc_hd__decap_3
XFILLER_58_648 VGND VGND VPWR VPWR sky130_fd_sc_hd__decap_3
XFILLER_85_423 VGND VGND VPWR VPWR sky130_fd_sc_hd__decap_3
Xhold1102 _7381_/Q VGND VGND VPWR VPWR _3901_/A1 sky130_fd_sc_hd__dlygate4sd3_1
Xhold1113 _7258_/Q VGND VGND VPWR VPWR _5063_/A0 sky130_fd_sc_hd__dlygate4sd3_1
Xhold1124 _7205_/Q VGND VGND VPWR VPWR _5249_/A0 sky130_fd_sc_hd__dlygate4sd3_1
XFILLER_57_169 VGND VGND VPWR VPWR sky130_fd_sc_hd__decap_3
Xhold1135 _7276_/Q VGND VGND VPWR VPWR _4753_/A0 sky130_fd_sc_hd__dlygate4sd3_1
Xhold1146 _7255_/Q VGND VGND VPWR VPWR _5108_/A0 sky130_fd_sc_hd__dlygate4sd3_1
Xhold1157 _7243_/Q VGND VGND VPWR VPWR _5169_/A sky130_fd_sc_hd__dlygate4sd3_1
X_5027_ _4910_/A _5024_/X _6990_/D _5666_/A VGND VGND VPWR VPWR _5027_/X sky130_fd_sc_hd__a22o_2
XFILLER_26_501 VGND VGND VPWR VPWR sky130_fd_sc_hd__decap_3
XFILLER_26_523 VGND VGND VPWR VPWR sky130_fd_sc_hd__fill_1
XFILLER_66_681 VGND VGND VPWR VPWR sky130_fd_sc_hd__decap_3
XFILLER_73_629 VGND VGND VPWR VPWR sky130_fd_sc_hd__decap_3
Xhold1168 _7339_/Q VGND VGND VPWR VPWR _4480_/A0 sky130_fd_sc_hd__dlygate4sd3_1
Xhold1179 _7207_/Q VGND VGND VPWR VPWR _5245_/A0 sky130_fd_sc_hd__dlygate4sd3_1
XFILLER_54_27 VGND VGND VPWR VPWR sky130_fd_sc_hd__fill_1
XFILLER_65_191 VGND VGND VPWR VPWR sky130_fd_sc_hd__decap_3
XFILLER_72_139 VGND VGND VPWR VPWR sky130_fd_sc_hd__fill_1
XFILLER_14_707 VGND VGND VPWR VPWR sky130_fd_sc_hd__decap_3
XFILLER_26_589 VGND VGND VPWR VPWR sky130_fd_sc_hd__decap_3
XFILLER_41_515 VGND VGND VPWR VPWR sky130_fd_sc_hd__decap_3
XFILLER_53_364 VGND VGND VPWR VPWR sky130_fd_sc_hd__decap_3
XFILLER_80_161 VGND VGND VPWR VPWR sky130_fd_sc_hd__decap_3
XFILLER_81_662 VGND VGND VPWR VPWR sky130_fd_sc_hd__decap_3
XFILLER_81_673 VGND VGND VPWR VPWR sky130_fd_sc_hd__decap_3
XFILLER_110_11 VGND VGND VPWR VPWR sky130_fd_sc_hd__decap_3
XFILLER_110_44 VGND VGND VPWR VPWR sky130_fd_sc_hd__decap_3
XFILLER_80_183 VGND VGND VPWR VPWR sky130_fd_sc_hd__decap_3
X_6978_ clkload6/A _6978_/D VGND VGND VPWR VPWR _6978_/Q sky130_fd_sc_hd__dfxtp_2
XTAP_TAPCELL_ROW_101_1524 VGND VPWR sky130_fd_sc_hd__tapvpwrvgnd_1
XFILLER_110_77 VGND VGND VPWR VPWR sky130_fd_sc_hd__decap_3
XFILLER_41_559 VGND VGND VPWR VPWR sky130_fd_sc_hd__fill_1
XFILLER_110_88 VGND VGND VPWR VPWR sky130_fd_sc_hd__decap_3
XFILLER_21_272 VGND VGND VPWR VPWR sky130_fd_sc_hd__decap_3
XFILLER_21_294 VGND VGND VPWR VPWR sky130_fd_sc_hd__fill_1
XFILLER_119_42 VGND VGND VPWR VPWR sky130_fd_sc_hd__decap_3
XFILLER_107_333 VGND VGND VPWR VPWR sky130_fd_sc_hd__decap_3
XFILLER_107_355 VGND VGND VPWR VPWR sky130_fd_sc_hd__decap_3
XFILLER_119_75 VGND VGND VPWR VPWR sky130_fd_sc_hd__decap_3
XFILLER_5_449 VGND VGND VPWR VPWR sky130_fd_sc_hd__decap_3
XFILLER_79_24 VGND VGND VPWR VPWR sky130_fd_sc_hd__decap_3
XFILLER_107_388 VGND VGND VPWR VPWR sky130_fd_sc_hd__decap_3
XFILLER_1_600 VGND VGND VPWR VPWR sky130_fd_sc_hd__decap_3
XFILLER_79_57 VGND VGND VPWR VPWR sky130_fd_sc_hd__decap_3
XFILLER_1_644 VGND VGND VPWR VPWR sky130_fd_sc_hd__decap_3
Xhold980 _7093_/Q VGND VGND VPWR VPWR _7093_/D sky130_fd_sc_hd__dlygate4sd3_1
Xhold991 _7075_/Q VGND VGND VPWR VPWR _7075_/D sky130_fd_sc_hd__dlygate4sd3_1
XTAP_TAPCELL_ROW_112_1653 VGND VPWR sky130_fd_sc_hd__tapvpwrvgnd_1
XFILLER_103_561 VGND VGND VPWR VPWR sky130_fd_sc_hd__decap_3
XTAP_TAPCELL_ROW_112_1664 VGND VPWR sky130_fd_sc_hd__tapvpwrvgnd_1
XFILLER_1_688 VGND VGND VPWR VPWR sky130_fd_sc_hd__decap_3
XFILLER_49_626 VGND VGND VPWR VPWR sky130_fd_sc_hd__decap_3
XFILLER_36_309 VGND VGND VPWR VPWR sky130_fd_sc_hd__decap_3
XFILLER_48_136 VGND VGND VPWR VPWR sky130_fd_sc_hd__decap_3
XFILLER_48_147 VGND VGND VPWR VPWR sky130_fd_sc_hd__decap_3
XFILLER_49_659 VGND VGND VPWR VPWR sky130_fd_sc_hd__decap_3
XFILLER_64_607 VGND VGND VPWR VPWR sky130_fd_sc_hd__decap_3
XFILLER_76_456 VGND VGND VPWR VPWR sky130_fd_sc_hd__decap_3
XFILLER_17_501 VGND VGND VPWR VPWR sky130_fd_sc_hd__decap_3
XFILLER_29_361 VGND VGND VPWR VPWR sky130_fd_sc_hd__decap_3
XFILLER_48_169 VGND VGND VPWR VPWR sky130_fd_sc_hd__decap_3
XFILLER_63_128 VGND VGND VPWR VPWR sky130_fd_sc_hd__decap_3
XFILLER_76_489 VGND VGND VPWR VPWR sky130_fd_sc_hd__decap_3
XFILLER_91_415 VGND VGND VPWR VPWR sky130_fd_sc_hd__decap_3
XFILLER_72_640 VGND VGND VPWR VPWR sky130_fd_sc_hd__decap_3
XTAP_TAPCELL_ROW_47_849 VGND VPWR sky130_fd_sc_hd__tapvpwrvgnd_1
XFILLER_17_578 VGND VGND VPWR VPWR sky130_fd_sc_hd__decap_3
XFILLER_71_150 VGND VGND VPWR VPWR sky130_fd_sc_hd__decap_3
XFILLER_72_651 VGND VGND VPWR VPWR sky130_fd_sc_hd__decap_3
XFILLER_72_684 VGND VGND VPWR VPWR sky130_fd_sc_hd__decap_3
XFILLER_44_71 VGND VGND VPWR VPWR sky130_fd_sc_hd__decap_3
XFILLER_71_172 VGND VGND VPWR VPWR sky130_fd_sc_hd__decap_3
XTAP_TAPCELL_ROW_27_595 VGND VPWR sky130_fd_sc_hd__tapvpwrvgnd_1
XFILLER_9_700 VGND VGND VPWR VPWR sky130_fd_sc_hd__decap_3
XFILLER_117_108 VGND VGND VPWR VPWR sky130_fd_sc_hd__fill_1
XFILLER_8_287 VGND VGND VPWR VPWR sky130_fd_sc_hd__decap_3
X_4260_ _7262_/Q _4356_/A2 _3964_/S _7326_/Q VGND VGND VPWR VPWR _4264_/A sky130_fd_sc_hd__a22o_2
XFILLER_86_209 VGND VGND VPWR VPWR sky130_fd_sc_hd__decap_3
X_4191_ _7071_/Q _4265_/B _4205_/A VGND VGND VPWR VPWR _4637_/C sky130_fd_sc_hd__o21a_2
XFILLER_67_423 VGND VGND VPWR VPWR sky130_fd_sc_hd__decap_3
XFILLER_79_261 VGND VGND VPWR VPWR sky130_fd_sc_hd__decap_3
XPHY_EDGE_ROW_105_Left_225 VGND VGND VPWR VPWR sky130_fd_sc_hd__decap_3
XFILLER_39_147 VGND VGND VPWR VPWR sky130_fd_sc_hd__decap_3
XFILLER_94_253 VGND VGND VPWR VPWR sky130_fd_sc_hd__decap_3
XFILLER_27_309 VGND VGND VPWR VPWR sky130_fd_sc_hd__decap_3
XFILLER_39_169 VGND VGND VPWR VPWR sky130_fd_sc_hd__decap_3
XFILLER_48_681 VGND VGND VPWR VPWR sky130_fd_sc_hd__decap_3
XFILLER_54_117 VGND VGND VPWR VPWR sky130_fd_sc_hd__decap_3
XFILLER_55_629 VGND VGND VPWR VPWR sky130_fd_sc_hd__decap_3
XFILLER_94_275 VGND VGND VPWR VPWR sky130_fd_sc_hd__decap_3
XFILLER_35_331 VGND VGND VPWR VPWR sky130_fd_sc_hd__decap_3
XFILLER_82_448 VGND VGND VPWR VPWR sky130_fd_sc_hd__fill_2
X_6901_ clkload7/A _6901_/D VGND VGND VPWR VPWR _6901_/Q sky130_fd_sc_hd__dfxtp_2
XFILLER_62_150 VGND VGND VPWR VPWR sky130_fd_sc_hd__decap_3
XFILLER_63_662 VGND VGND VPWR VPWR sky130_fd_sc_hd__decap_3
XFILLER_63_673 VGND VGND VPWR VPWR sky130_fd_sc_hd__decap_3
X_6832_ clkload5/A _6832_/D VGND VGND VPWR VPWR _6832_/Q sky130_fd_sc_hd__dfxtp_2
XFILLER_50_312 VGND VGND VPWR VPWR sky130_fd_sc_hd__decap_3
XFILLER_62_161 VGND VGND VPWR VPWR sky130_fd_sc_hd__decap_3
XFILLER_62_183 VGND VGND VPWR VPWR sky130_fd_sc_hd__decap_3
XFILLER_90_470 VGND VGND VPWR VPWR sky130_fd_sc_hd__decap_3
X_6763_ _6968_/CLK _6763_/D VGND VGND VPWR VPWR _6763_/Q sky130_fd_sc_hd__dfxtp_2
X_3975_ _7353_/Q _4517_/A0 _3975_/S VGND VGND VPWR VPWR _7353_/D sky130_fd_sc_hd__mux2_2
XPHY_EDGE_ROW_114_Left_234 VGND VGND VPWR VPWR sky130_fd_sc_hd__decap_3
X_6694_ _7345_/CLK _6694_/D VGND VGND VPWR VPWR _6694_/Q sky130_fd_sc_hd__dfxtp_2
XFILLER_31_592 VGND VGND VPWR VPWR sky130_fd_sc_hd__decap_3
X_5645_ _5129_/A _5129_/B _3519_/B _5644_/X VGND VGND VPWR VPWR _5645_/X sky130_fd_sc_hd__o31a_2
XFILLER_117_620 VGND VGND VPWR VPWR sky130_fd_sc_hd__decap_3
XFILLER_40_29 VGND VGND VPWR VPWR sky130_fd_sc_hd__decap_3
XFILLER_116_130 VGND VGND VPWR VPWR sky130_fd_sc_hd__decap_3
XFILLER_117_653 VGND VGND VPWR VPWR sky130_fd_sc_hd__decap_3
X_5576_ _5576_/A1 _4960_/A _5015_/X VGND VGND VPWR VPWR _7041_/D sky130_fd_sc_hd__a21o_2
XFILLER_116_141 VGND VGND VPWR VPWR sky130_fd_sc_hd__decap_3
XFILLER_117_697 VGND VGND VPWR VPWR sky130_fd_sc_hd__decap_3
X_7315_ _7350_/CLK _7315_/D _6595_/Y VGND VGND VPWR VPWR _7315_/Q sky130_fd_sc_hd__dfrtp_2
XFILLER_104_336 VGND VGND VPWR VPWR sky130_fd_sc_hd__decap_3
XFILLER_116_174 VGND VGND VPWR VPWR sky130_fd_sc_hd__decap_3
X_7246_ _7374_/CLK _7246_/D _6526_/Y VGND VGND VPWR VPWR _7246_/Q sky130_fd_sc_hd__dfrtp_2
X_4458_ _4458_/A _4039_/A VGND VGND VPWR VPWR _4458_/X sky130_fd_sc_hd__or2b_2
X_7177_ _7402_/CLK _7177_/D _6457_/Y VGND VGND VPWR VPWR _7177_/Q sky130_fd_sc_hd__dfrtp_2
X_3409_ _3449_/A _3449_/B _3421_/C _3409_/D VGND VGND VPWR VPWR _3409_/X sky130_fd_sc_hd__and4_2
XFILLER_86_710 VGND VGND VPWR VPWR sky130_fd_sc_hd__decap_3
X_4389_ _7081_/Q _4102_/B _4432_/B1 _4388_/X VGND VGND VPWR VPWR _4396_/A sky130_fd_sc_hd__o211ai_2
XFILLER_105_55 VGND VGND VPWR VPWR sky130_fd_sc_hd__fill_1
XFILLER_112_391 VGND VGND VPWR VPWR sky130_fd_sc_hd__decap_3
XFILLER_46_607 VGND VGND VPWR VPWR sky130_fd_sc_hd__decap_3
XFILLER_85_231 VGND VGND VPWR VPWR sky130_fd_sc_hd__decap_3
XFILLER_100_586 VGND VGND VPWR VPWR sky130_fd_sc_hd__fill_2
XFILLER_105_77 VGND VGND VPWR VPWR sky130_fd_sc_hd__decap_3
XFILLER_18_309 VGND VGND VPWR VPWR sky130_fd_sc_hd__decap_3
XFILLER_38_191 VGND VGND VPWR VPWR sky130_fd_sc_hd__decap_3
XFILLER_53_150 VGND VGND VPWR VPWR sky130_fd_sc_hd__fill_1
XFILLER_54_651 VGND VGND VPWR VPWR sky130_fd_sc_hd__decap_3
XTAP_TAPCELL_ROW_44_808 VGND VPWR sky130_fd_sc_hd__tapvpwrvgnd_1
XFILLER_14_515 VGND VGND VPWR VPWR sky130_fd_sc_hd__decap_3
XFILLER_41_323 VGND VGND VPWR VPWR sky130_fd_sc_hd__decap_3
XFILLER_54_684 VGND VGND VPWR VPWR sky130_fd_sc_hd__decap_3
XFILLER_41_334 VGND VGND VPWR VPWR sky130_fd_sc_hd__fill_2
XFILLER_53_194 VGND VGND VPWR VPWR sky130_fd_sc_hd__decap_3
XFILLER_81_69 VGND VGND VPWR VPWR sky130_fd_sc_hd__decap_3
XTAP_TAPCELL_ROW_24_554 VGND VPWR sky130_fd_sc_hd__tapvpwrvgnd_1
XFILLER_10_710 VGND VGND VPWR VPWR sky130_fd_sc_hd__decap_3
XFILLER_14_85 VGND VGND VPWR VPWR sky130_fd_sc_hd__decap_3
XFILLER_22_592 VGND VGND VPWR VPWR sky130_fd_sc_hd__decap_3
XFILLER_108_631 VGND VGND VPWR VPWR sky130_fd_sc_hd__decap_3
XFILLER_107_152 VGND VGND VPWR VPWR sky130_fd_sc_hd__decap_3
XFILLER_108_675 VGND VGND VPWR VPWR sky130_fd_sc_hd__decap_3
XFILLER_1_463 VGND VGND VPWR VPWR sky130_fd_sc_hd__decap_3
XFILLER_103_380 VGND VGND VPWR VPWR sky130_fd_sc_hd__decap_3
XFILLER_1_496 VGND VGND VPWR VPWR sky130_fd_sc_hd__decap_3
XFILLER_76_231 VGND VGND VPWR VPWR sky130_fd_sc_hd__decap_3
XFILLER_37_629 VGND VGND VPWR VPWR sky130_fd_sc_hd__decap_3
XFILLER_76_286 VGND VGND VPWR VPWR sky130_fd_sc_hd__decap_3
XFILLER_92_713 VGND VGND VPWR VPWR sky130_fd_sc_hd__fill_1
XFILLER_17_320 VGND VGND VPWR VPWR sky130_fd_sc_hd__decap_3
XFILLER_91_245 VGND VGND VPWR VPWR sky130_fd_sc_hd__decap_3
XFILLER_17_353 VGND VGND VPWR VPWR sky130_fd_sc_hd__decap_3
XFILLER_45_662 VGND VGND VPWR VPWR sky130_fd_sc_hd__decap_3
XFILLER_45_673 VGND VGND VPWR VPWR sky130_fd_sc_hd__decap_3
XFILLER_55_92 VGND VGND VPWR VPWR sky130_fd_sc_hd__decap_3
XFILLER_72_492 VGND VGND VPWR VPWR sky130_fd_sc_hd__decap_3
XFILLER_60_643 VGND VGND VPWR VPWR sky130_fd_sc_hd__fill_1
XFILLER_60_654 VGND VGND VPWR VPWR sky130_fd_sc_hd__decap_3
XFILLER_13_570 VGND VGND VPWR VPWR sky130_fd_sc_hd__decap_3
XFILLER_20_507 VGND VGND VPWR VPWR sky130_fd_sc_hd__fill_2
XFILLER_20_518 VGND VGND VPWR VPWR sky130_fd_sc_hd__decap_3
XFILLER_60_687 VGND VGND VPWR VPWR sky130_fd_sc_hd__decap_3
X_3760_ _6933_/Q _3760_/A2 _3760_/B1 _6707_/Q VGND VGND VPWR VPWR _3760_/X sky130_fd_sc_hd__a22o_2
XFILLER_118_417 VGND VGND VPWR VPWR sky130_fd_sc_hd__decap_3
X_3691_ _6941_/Q _3760_/A2 _3759_/A2 _6805_/Q VGND VGND VPWR VPWR _3691_/X sky130_fd_sc_hd__a22o_2
XFILLER_9_585 VGND VGND VPWR VPWR sky130_fd_sc_hd__decap_3
XTAP_TAPCELL_ROW_76_1209 VGND VPWR sky130_fd_sc_hd__tapvpwrvgnd_1
XFILLER_114_601 VGND VGND VPWR VPWR sky130_fd_sc_hd__decap_3
XFILLER_113_122 VGND VGND VPWR VPWR sky130_fd_sc_hd__decap_3
XFILLER_114_634 VGND VGND VPWR VPWR sky130_fd_sc_hd__decap_3
XFILLER_114_645 VGND VGND VPWR VPWR sky130_fd_sc_hd__decap_3
X_7100_ _7360_/CLK _7100_/D _6380_/Y VGND VGND VPWR VPWR _7100_/Q sky130_fd_sc_hd__dfrtp_2
X_5292_ _5292_/A0 _4470_/X _5292_/S VGND VGND VPWR VPWR _7183_/D sky130_fd_sc_hd__mux2_2
X_4312_ _4394_/A _4337_/B _4311_/X VGND VGND VPWR VPWR _4313_/D sky130_fd_sc_hd__or3b_2
XFILLER_113_144 VGND VGND VPWR VPWR sky130_fd_sc_hd__decap_3
XFILLER_114_678 VGND VGND VPWR VPWR sky130_fd_sc_hd__decap_3
X_7031_ _7355_/CLK _7031_/D _6311_/Y VGND VGND VPWR VPWR _7031_/Q sky130_fd_sc_hd__dfrtp_2
X_4243_ _4620_/A _5032_/A VGND VGND VPWR VPWR _4243_/Y sky130_fd_sc_hd__nor2_2
XFILLER_99_367 VGND VGND VPWR VPWR sky130_fd_sc_hd__decap_3
XFILLER_113_166 VGND VGND VPWR VPWR sky130_fd_sc_hd__fill_2
XFILLER_113_177 VGND VGND VPWR VPWR sky130_fd_sc_hd__decap_3
XFILLER_68_710 VGND VGND VPWR VPWR sky130_fd_sc_hd__decap_3
XFILLER_28_607 VGND VGND VPWR VPWR sky130_fd_sc_hd__decap_3
XFILLER_95_540 VGND VGND VPWR VPWR sky130_fd_sc_hd__decap_3
X_4174_ _7296_/Q _4419_/A2 _4338_/B1 _7360_/Q VGND VGND VPWR VPWR _4174_/X sky130_fd_sc_hd__a22o_2
XFILLER_95_573 VGND VGND VPWR VPWR sky130_fd_sc_hd__decap_3
XFILLER_27_128 VGND VGND VPWR VPWR sky130_fd_sc_hd__decap_3
XFILLER_82_234 VGND VGND VPWR VPWR sky130_fd_sc_hd__fill_2
XTAP_TAPCELL_ROW_87_1349 VGND VPWR sky130_fd_sc_hd__tapvpwrvgnd_1
XFILLER_36_640 VGND VGND VPWR VPWR sky130_fd_sc_hd__decap_3
XFILLER_36_651 VGND VGND VPWR VPWR sky130_fd_sc_hd__decap_3
XFILLER_82_256 VGND VGND VPWR VPWR sky130_fd_sc_hd__decap_3
XFILLER_23_312 VGND VGND VPWR VPWR sky130_fd_sc_hd__decap_3
XFILLER_36_684 VGND VGND VPWR VPWR sky130_fd_sc_hd__decap_3
XFILLER_51_632 VGND VGND VPWR VPWR sky130_fd_sc_hd__decap_3
XFILLER_23_334 VGND VGND VPWR VPWR sky130_fd_sc_hd__fill_2
XFILLER_23_356 VGND VGND VPWR VPWR sky130_fd_sc_hd__decap_3
XFILLER_50_131 VGND VGND VPWR VPWR sky130_fd_sc_hd__fill_1
XFILLER_51_665 VGND VGND VPWR VPWR sky130_fd_sc_hd__decap_3
Xplace492 _5581_/S VGND VGND VPWR VPWR _5579_/S sky130_fd_sc_hd__buf_2
Xplace481 _3994_/S VGND VGND VPWR VPWR _4471_/S sky130_fd_sc_hd__buf_2
Xplace470 _3380_/Y VGND VGND VPWR VPWR _4261_/A2 sky130_fd_sc_hd__buf_2
X_6815_ clkload4/A _6815_/D VGND VGND VPWR VPWR _6815_/Q sky130_fd_sc_hd__dfxtp_2
XFILLER_51_676 VGND VGND VPWR VPWR sky130_fd_sc_hd__decap_3
X_6746_ _7189_/CLK _6746_/D VGND VGND VPWR VPWR _6746_/Q sky130_fd_sc_hd__dfxtp_2
XFILLER_50_197 VGND VGND VPWR VPWR sky130_fd_sc_hd__decap_3
X_3958_ _7361_/Q _4501_/A0 _3964_/S VGND VGND VPWR VPWR _7361_/D sky130_fd_sc_hd__mux2_2
XTAP_TAPCELL_ROW_21_524 VGND VPWR sky130_fd_sc_hd__tapvpwrvgnd_1
X_6677_ _6677_/A VGND VGND VPWR VPWR _6677_/Y sky130_fd_sc_hd__inv_2
X_3889_ _6834_/Q _3910_/B1 _3889_/B1 _6829_/Q _3888_/X VGND VGND VPWR VPWR _3889_/X
+ sky130_fd_sc_hd__a221o_2
X_5628_ _5628_/A _5633_/B VGND VGND VPWR VPWR _7014_/D sky130_fd_sc_hd__or2_2
XTAP_TAPCELL_ROW_98_1489 VGND VPWR sky130_fd_sc_hd__tapvpwrvgnd_1
XTAP_TAPCELL_ROW_98_1478 VGND VPWR sky130_fd_sc_hd__tapvpwrvgnd_1
XFILLER_105_612 VGND VGND VPWR VPWR sky130_fd_sc_hd__decap_3
XFILLER_117_461 VGND VGND VPWR VPWR sky130_fd_sc_hd__decap_3
XFILLER_3_706 VGND VGND VPWR VPWR sky130_fd_sc_hd__decap_3
XFILLER_105_623 VGND VGND VPWR VPWR sky130_fd_sc_hd__decap_3
XFILLER_104_144 VGND VGND VPWR VPWR sky130_fd_sc_hd__decap_3
XFILLER_105_656 VGND VGND VPWR VPWR sky130_fd_sc_hd__decap_3
XFILLER_116_21 VGND VGND VPWR VPWR sky130_fd_sc_hd__decap_3
XFILLER_116_32 VGND VGND VPWR VPWR sky130_fd_sc_hd__decap_3
XFILLER_104_177 VGND VGND VPWR VPWR sky130_fd_sc_hd__decap_3
XFILLER_116_65 VGND VGND VPWR VPWR sky130_fd_sc_hd__decap_3
XFILLER_78_529 VGND VGND VPWR VPWR sky130_fd_sc_hd__decap_3
X_7229_ _7358_/CLK _7229_/D _6509_/Y VGND VGND VPWR VPWR _7229_/Q sky130_fd_sc_hd__dfrtp_2
XFILLER_58_242 VGND VGND VPWR VPWR sky130_fd_sc_hd__decap_3
XFILLER_18_106 VGND VGND VPWR VPWR sky130_fd_sc_hd__decap_3
XFILLER_19_607 VGND VGND VPWR VPWR sky130_fd_sc_hd__decap_3
XFILLER_19_629 VGND VGND VPWR VPWR sky130_fd_sc_hd__decap_3
XFILLER_46_404 VGND VGND VPWR VPWR sky130_fd_sc_hd__decap_3
XFILLER_58_275 VGND VGND VPWR VPWR sky130_fd_sc_hd__decap_3
XFILLER_73_201 VGND VGND VPWR VPWR sky130_fd_sc_hd__decap_3
XFILLER_74_713 VGND VGND VPWR VPWR sky130_fd_sc_hd__fill_1
XFILLER_100_372 VGND VGND VPWR VPWR sky130_fd_sc_hd__decap_3
XFILLER_46_459 VGND VGND VPWR VPWR sky130_fd_sc_hd__decap_3
XFILLER_58_297 VGND VGND VPWR VPWR sky130_fd_sc_hd__decap_3
XFILLER_73_234 VGND VGND VPWR VPWR sky130_fd_sc_hd__decap_3
XFILLER_86_595 VGND VGND VPWR VPWR sky130_fd_sc_hd__fill_1
XTAP_TAPCELL_ROW_29_624 VGND VPWR sky130_fd_sc_hd__tapvpwrvgnd_1
XFILLER_27_662 VGND VGND VPWR VPWR sky130_fd_sc_hd__decap_3
XFILLER_33_109 VGND VGND VPWR VPWR sky130_fd_sc_hd__decap_3
XFILLER_73_278 VGND VGND VPWR VPWR sky130_fd_sc_hd__fill_2
XFILLER_92_24 VGND VGND VPWR VPWR sky130_fd_sc_hd__decap_3
XFILLER_92_35 VGND VGND VPWR VPWR sky130_fd_sc_hd__decap_3
XTAP_TAPCELL_ROW_57_966 VGND VPWR sky130_fd_sc_hd__tapvpwrvgnd_1
XFILLER_14_312 VGND VGND VPWR VPWR sky130_fd_sc_hd__decap_3
XFILLER_27_673 VGND VGND VPWR VPWR sky130_fd_sc_hd__decap_3
XFILLER_42_621 VGND VGND VPWR VPWR sky130_fd_sc_hd__decap_3
XFILLER_54_470 VGND VGND VPWR VPWR sky130_fd_sc_hd__decap_3
XFILLER_92_57 VGND VGND VPWR VPWR sky130_fd_sc_hd__decap_3
XTAP_TAPCELL_ROW_1_271 VGND VPWR sky130_fd_sc_hd__tapvpwrvgnd_1
XFILLER_42_654 VGND VGND VPWR VPWR sky130_fd_sc_hd__decap_3
XTAP_TAPCELL_ROW_107_1596 VGND VPWR sky130_fd_sc_hd__tapvpwrvgnd_1
XFILLER_25_84 VGND VGND VPWR VPWR sky130_fd_sc_hd__decap_3
XFILLER_42_687 VGND VGND VPWR VPWR sky130_fd_sc_hd__decap_3
XFILLER_41_186 VGND VGND VPWR VPWR sky130_fd_sc_hd__fill_1
XFILLER_10_551 VGND VGND VPWR VPWR sky130_fd_sc_hd__decap_3
XFILLER_10_584 VGND VGND VPWR VPWR sky130_fd_sc_hd__decap_3
XFILLER_10_595 VGND VGND VPWR VPWR sky130_fd_sc_hd__decap_3
XFILLER_115_409 VGND VGND VPWR VPWR sky130_fd_sc_hd__decap_3
XFILLER_6_566 VGND VGND VPWR VPWR sky130_fd_sc_hd__decap_3
XFILLER_108_472 VGND VGND VPWR VPWR sky130_fd_sc_hd__decap_3
XFILLER_108_483 VGND VGND VPWR VPWR sky130_fd_sc_hd__decap_3
XFILLER_110_103 VGND VGND VPWR VPWR sky130_fd_sc_hd__decap_3
XFILLER_111_615 VGND VGND VPWR VPWR sky130_fd_sc_hd__fill_1
XFILLER_111_626 VGND VGND VPWR VPWR sky130_fd_sc_hd__decap_3
XFILLER_69_529 VGND VGND VPWR VPWR sky130_fd_sc_hd__decap_3
XTAP_TAPCELL_ROW_9_371 VGND VPWR sky130_fd_sc_hd__tapvpwrvgnd_1
XFILLER_110_136 VGND VGND VPWR VPWR sky130_fd_sc_hd__decap_3
XFILLER_111_659 VGND VGND VPWR VPWR sky130_fd_sc_hd__decap_3
XFILLER_1_271 VGND VGND VPWR VPWR sky130_fd_sc_hd__decap_3
XFILLER_49_231 VGND VGND VPWR VPWR sky130_fd_sc_hd__decap_3
XFILLER_92_510 VGND VGND VPWR VPWR sky130_fd_sc_hd__decap_3
XFILLER_2_88 VGND VGND VPWR VPWR sky130_fd_sc_hd__fill_2
XFILLER_18_640 VGND VGND VPWR VPWR sky130_fd_sc_hd__decap_3
XFILLER_18_651 VGND VGND VPWR VPWR sky130_fd_sc_hd__decap_3
XFILLER_66_91 VGND VGND VPWR VPWR sky130_fd_sc_hd__decap_3
XFILLER_18_684 VGND VGND VPWR VPWR sky130_fd_sc_hd__decap_3
X_4930_ _6995_/Q _4963_/A _6996_/Q VGND VGND VPWR VPWR _4931_/B sky130_fd_sc_hd__a21oi_2
XFILLER_32_131 VGND VGND VPWR VPWR sky130_fd_sc_hd__decap_3
XFILLER_33_632 VGND VGND VPWR VPWR sky130_fd_sc_hd__decap_3
XFILLER_33_665 VGND VGND VPWR VPWR sky130_fd_sc_hd__decap_3
X_4861_ _6998_/Q _6999_/Q _4912_/A _7000_/Q VGND VGND VPWR VPWR _4862_/B sky130_fd_sc_hd__a31o_2
XFILLER_20_315 VGND VGND VPWR VPWR sky130_fd_sc_hd__decap_3
XFILLER_33_676 VGND VGND VPWR VPWR sky130_fd_sc_hd__decap_3
XFILLER_60_462 VGND VGND VPWR VPWR sky130_fd_sc_hd__decap_3
X_6600_ _6624_/A VGND VGND VPWR VPWR _6600_/Y sky130_fd_sc_hd__inv_2
X_3812_ _3725_/X _3804_/X _3806_/X _3728_/Y _3811_/X VGND VGND VPWR VPWR _3812_/X
+ sky130_fd_sc_hd__a221o_2
XTAP_TAPCELL_ROW_82_1279 VGND VPWR sky130_fd_sc_hd__tapvpwrvgnd_1
XFILLER_119_704 VGND VGND VPWR VPWR sky130_fd_sc_hd__fill_2
XFILLER_32_175 VGND VGND VPWR VPWR sky130_fd_sc_hd__decap_3
XFILLER_32_197 VGND VGND VPWR VPWR sky130_fd_sc_hd__decap_3
X_4792_ _5666_/A _7004_/D _4777_/X _4791_/Y VGND VGND VPWR VPWR _4792_/X sky130_fd_sc_hd__a211o_2
XFILLER_118_203 VGND VGND VPWR VPWR sky130_fd_sc_hd__decap_3
X_6531_ _6630_/A VGND VGND VPWR VPWR _6531_/Y sky130_fd_sc_hd__inv_2
X_3743_ _6848_/Q _3851_/A2 _3886_/B1 _6838_/Q _3742_/X VGND VGND VPWR VPWR _3743_/X
+ sky130_fd_sc_hd__a221o_2
XFILLER_9_360 VGND VGND VPWR VPWR sky130_fd_sc_hd__decap_3
XFILLER_118_236 VGND VGND VPWR VPWR sky130_fd_sc_hd__fill_1
X_6462_ _6653_/A VGND VGND VPWR VPWR _6462_/Y sky130_fd_sc_hd__inv_2
X_3674_ _6806_/Q VGND VGND VPWR VPWR _3674_/Y sky130_fd_sc_hd__inv_2
XFILLER_9_393 VGND VGND VPWR VPWR sky130_fd_sc_hd__decap_3
XFILLER_9_371 VGND VGND VPWR VPWR sky130_fd_sc_hd__decap_3
X_6393_ _6647_/A VGND VGND VPWR VPWR _6393_/Y sky130_fd_sc_hd__inv_2
X_5413_ _5413_/A0 _5107_/X _5427_/S VGND VGND VPWR VPWR _7127_/D sky130_fd_sc_hd__mux2_2
X_5344_ _5344_/A0 _5107_/X _7412_/A VGND VGND VPWR VPWR _7159_/D sky130_fd_sc_hd__mux2_2
XFILLER_114_431 VGND VGND VPWR VPWR sky130_fd_sc_hd__decap_3
XFILLER_114_464 VGND VGND VPWR VPWR sky130_fd_sc_hd__decap_3
XFILLER_99_142 VGND VGND VPWR VPWR sky130_fd_sc_hd__decap_3
XFILLER_99_131 VGND VGND VPWR VPWR sky130_fd_sc_hd__decap_3
XFILLER_102_637 VGND VGND VPWR VPWR sky130_fd_sc_hd__decap_3
XFILLER_102_648 VGND VGND VPWR VPWR sky130_fd_sc_hd__decap_3
XFILLER_87_337 VGND VGND VPWR VPWR sky130_fd_sc_hd__decap_3
X_7014_ _7322_/CLK _7014_/D _6294_/Y VGND VGND VPWR VPWR _7014_/Q sky130_fd_sc_hd__dfrtp_2
X_4226_ _4372_/A _4627_/A VGND VGND VPWR VPWR _4620_/A sky130_fd_sc_hd__nor2_2
XFILLER_99_197 VGND VGND VPWR VPWR sky130_fd_sc_hd__decap_3
XFILLER_101_169 VGND VGND VPWR VPWR sky130_fd_sc_hd__decap_3
XFILLER_28_404 VGND VGND VPWR VPWR sky130_fd_sc_hd__decap_3
XFILLER_56_713 VGND VGND VPWR VPWR sky130_fd_sc_hd__fill_1
X_4157_ _4157_/A _4205_/C VGND VGND VPWR VPWR _4158_/B sky130_fd_sc_hd__nand2_2
XFILLER_110_681 VGND VGND VPWR VPWR sky130_fd_sc_hd__decap_3
XFILLER_55_212 VGND VGND VPWR VPWR sky130_fd_sc_hd__decap_3
XFILLER_55_234 VGND VGND VPWR VPWR sky130_fd_sc_hd__decap_3
XFILLER_55_267 VGND VGND VPWR VPWR sky130_fd_sc_hd__decap_3
X_4088_ _7238_/Q _4433_/B _4244_/B _7051_/Q VGND VGND VPWR VPWR _4088_/X sky130_fd_sc_hd__a22o_2
XFILLER_24_610 VGND VGND VPWR VPWR sky130_fd_sc_hd__decap_3
XFILLER_36_481 VGND VGND VPWR VPWR sky130_fd_sc_hd__decap_3
XTAP_TAPCELL_ROW_54_936 VGND VPWR sky130_fd_sc_hd__tapvpwrvgnd_1
XFILLER_23_131 VGND VGND VPWR VPWR sky130_fd_sc_hd__decap_3
XFILLER_24_643 VGND VGND VPWR VPWR sky130_fd_sc_hd__fill_1
XFILLER_24_654 VGND VGND VPWR VPWR sky130_fd_sc_hd__decap_3
XFILLER_70_248 VGND VGND VPWR VPWR sky130_fd_sc_hd__decap_3
XFILLER_11_304 VGND VGND VPWR VPWR sky130_fd_sc_hd__decap_3
XFILLER_24_687 VGND VGND VPWR VPWR sky130_fd_sc_hd__decap_3
XFILLER_62_49 VGND VGND VPWR VPWR sky130_fd_sc_hd__fill_1
XFILLER_11_326 VGND VGND VPWR VPWR sky130_fd_sc_hd__fill_1
XFILLER_11_337 VGND VGND VPWR VPWR sky130_fd_sc_hd__fill_1
XTAP_TAPCELL_ROW_34_682 VGND VPWR sky130_fd_sc_hd__tapvpwrvgnd_1
XFILLER_7_308 VGND VGND VPWR VPWR sky130_fd_sc_hd__decap_3
X_6729_ _6906_/CLK _6729_/D VGND VGND VPWR VPWR _6729_/Q sky130_fd_sc_hd__dfxtp_2
XFILLER_109_225 VGND VGND VPWR VPWR sky130_fd_sc_hd__decap_3
XFILLER_109_258 VGND VGND VPWR VPWR sky130_fd_sc_hd__decap_3
XFILLER_11_53 VGND VGND VPWR VPWR sky130_fd_sc_hd__decap_3
XFILLER_3_514 VGND VGND VPWR VPWR sky130_fd_sc_hd__decap_3
XFILLER_3_547 VGND VGND VPWR VPWR sky130_fd_sc_hd__decap_3
XFILLER_105_464 VGND VGND VPWR VPWR sky130_fd_sc_hd__decap_3
XFILLER_78_315 VGND VGND VPWR VPWR sky130_fd_sc_hd__decap_3
XFILLER_87_57 VGND VGND VPWR VPWR sky130_fd_sc_hd__decap_3
XTAP_TAPCELL_ROW_6_330 VGND VPWR sky130_fd_sc_hd__tapvpwrvgnd_1
XFILLER_46_223 VGND VGND VPWR VPWR sky130_fd_sc_hd__decap_3
XTAP_TAPCELL_ROW_109_1625 VGND VPWR sky130_fd_sc_hd__tapvpwrvgnd_1
XFILLER_46_245 VGND VGND VPWR VPWR sky130_fd_sc_hd__decap_3
XFILLER_46_256 VGND VGND VPWR VPWR sky130_fd_sc_hd__fill_1
XFILLER_34_429 VGND VGND VPWR VPWR sky130_fd_sc_hd__decap_3
XFILLER_46_289 VGND VGND VPWR VPWR sky130_fd_sc_hd__decap_3
XFILLER_15_632 VGND VGND VPWR VPWR sky130_fd_sc_hd__decap_3
XFILLER_36_83 VGND VGND VPWR VPWR sky130_fd_sc_hd__fill_1
XFILLER_15_665 VGND VGND VPWR VPWR sky130_fd_sc_hd__decap_3
XFILLER_15_676 VGND VGND VPWR VPWR sky130_fd_sc_hd__decap_3
XFILLER_30_613 VGND VGND VPWR VPWR sky130_fd_sc_hd__decap_3
XFILLER_99_9 VGND VGND VPWR VPWR sky130_fd_sc_hd__decap_3
XFILLER_14_175 VGND VGND VPWR VPWR sky130_fd_sc_hd__decap_3
XFILLER_14_197 VGND VGND VPWR VPWR sky130_fd_sc_hd__decap_3
XFILLER_30_657 VGND VGND VPWR VPWR sky130_fd_sc_hd__decap_3
XFILLER_116_707 VGND VGND VPWR VPWR sky130_fd_sc_hd__decap_3
XFILLER_6_330 VGND VGND VPWR VPWR sky130_fd_sc_hd__decap_3
Xhold809 _6785_/Q VGND VGND VPWR VPWR _6785_/D sky130_fd_sc_hd__dlygate4sd3_1
XFILLER_115_217 VGND VGND VPWR VPWR sky130_fd_sc_hd__decap_3
X_3390_ _7155_/Q _4339_/B1 _3379_/X _3389_/X VGND VGND VPWR VPWR _3390_/X sky130_fd_sc_hd__a211o_2
XFILLER_97_635 VGND VGND VPWR VPWR sky130_fd_sc_hd__decap_3
XFILLER_69_337 VGND VGND VPWR VPWR sky130_fd_sc_hd__decap_3
XFILLER_96_134 VGND VGND VPWR VPWR sky130_fd_sc_hd__decap_3
XFILLER_97_668 VGND VGND VPWR VPWR sky130_fd_sc_hd__decap_3
X_5060_ _5579_/S _5045_/X _5059_/X _4467_/B VGND VGND VPWR VPWR _5060_/X sky130_fd_sc_hd__a22o_2
XFILLER_111_489 VGND VGND VPWR VPWR sky130_fd_sc_hd__decap_3
XFILLER_38_713 VGND VGND VPWR VPWR sky130_fd_sc_hd__fill_1
XFILLER_84_307 VGND VGND VPWR VPWR sky130_fd_sc_hd__fill_1
XFILLER_96_156 VGND VGND VPWR VPWR sky130_fd_sc_hd__decap_3
XFILLER_97_679 VGND VGND VPWR VPWR sky130_fd_sc_hd__decap_3
X_4011_ _7342_/Q _3954_/S _4419_/B1 _7374_/Q _4429_/C1 VGND VGND VPWR VPWR _4011_/X
+ sky130_fd_sc_hd__a221o_2
XFILLER_37_212 VGND VGND VPWR VPWR sky130_fd_sc_hd__decap_3
XFILLER_77_370 VGND VGND VPWR VPWR sky130_fd_sc_hd__decap_3
XFILLER_77_381 VGND VGND VPWR VPWR sky130_fd_sc_hd__decap_3
XFILLER_84_329 VGND VGND VPWR VPWR sky130_fd_sc_hd__decap_3
XFILLER_96_189 VGND VGND VPWR VPWR sky130_fd_sc_hd__decap_3
XFILLER_25_407 VGND VGND VPWR VPWR sky130_fd_sc_hd__decap_3
XFILLER_37_245 VGND VGND VPWR VPWR sky130_fd_sc_hd__decap_3
XFILLER_65_554 VGND VGND VPWR VPWR sky130_fd_sc_hd__decap_3
XFILLER_92_351 VGND VGND VPWR VPWR sky130_fd_sc_hd__decap_3
XTAP_TAPCELL_ROW_84_1308 VGND VPWR sky130_fd_sc_hd__tapvpwrvgnd_1
XFILLER_37_289 VGND VGND VPWR VPWR sky130_fd_sc_hd__decap_3
XFILLER_92_362 VGND VGND VPWR VPWR sky130_fd_sc_hd__fill_2
X_4913_ _5657_/B _3762_/X _4910_/Y _6997_/D _4836_/S VGND VGND VPWR VPWR _4913_/X
+ sky130_fd_sc_hd__o32a_2
XFILLER_21_635 VGND VGND VPWR VPWR sky130_fd_sc_hd__decap_3
XFILLER_33_495 VGND VGND VPWR VPWR sky130_fd_sc_hd__decap_3
X_4844_ _4633_/A _4111_/B _4842_/X _4843_/Y _4948_/A VGND VGND VPWR VPWR _4855_/A
+ sky130_fd_sc_hd__a311oi_2
XFILLER_119_501 VGND VGND VPWR VPWR sky130_fd_sc_hd__decap_3
XFILLER_119_512 VGND VGND VPWR VPWR sky130_fd_sc_hd__fill_2
XFILLER_21_668 VGND VGND VPWR VPWR sky130_fd_sc_hd__decap_3
XFILLER_21_679 VGND VGND VPWR VPWR sky130_fd_sc_hd__decap_3
X_4775_ _4775_/A _4775_/B VGND VGND VPWR VPWR _7004_/D sky130_fd_sc_hd__nor2_2
XTAP_TAPCELL_ROW_31_641 VGND VPWR sky130_fd_sc_hd__tapvpwrvgnd_1
X_6514_ _6613_/A VGND VGND VPWR VPWR _6514_/Y sky130_fd_sc_hd__inv_2
X_3726_ _3714_/X _3721_/X _3724_/X _3725_/X VGND VGND VPWR VPWR _3726_/X sky130_fd_sc_hd__a22o_2
X_6445_ _6638_/A VGND VGND VPWR VPWR _6445_/Y sky130_fd_sc_hd__inv_2
XTAP_TAPCELL_ROW_95_1448 VGND VPWR sky130_fd_sc_hd__tapvpwrvgnd_1
X_6376_ _6571_/A VGND VGND VPWR VPWR _6376_/Y sky130_fd_sc_hd__inv_2
XFILLER_0_528 VGND VGND VPWR VPWR sky130_fd_sc_hd__decap_3
XFILLER_102_412 VGND VGND VPWR VPWR sky130_fd_sc_hd__decap_3
XFILLER_114_261 VGND VGND VPWR VPWR sky130_fd_sc_hd__decap_3
XFILLER_88_602 VGND VGND VPWR VPWR sky130_fd_sc_hd__decap_3
XFILLER_88_624 VGND VGND VPWR VPWR sky130_fd_sc_hd__decap_3
X_5327_ _5327_/A0 _4978_/X _5340_/S VGND VGND VPWR VPWR _7167_/D sky130_fd_sc_hd__mux2_2
XFILLER_114_283 VGND VGND VPWR VPWR sky130_fd_sc_hd__fill_1
XFILLER_88_657 VGND VGND VPWR VPWR sky130_fd_sc_hd__decap_3
XFILLER_102_467 VGND VGND VPWR VPWR sky130_fd_sc_hd__decap_3
XFILLER_87_156 VGND VGND VPWR VPWR sky130_fd_sc_hd__decap_3
XFILLER_87_178 VGND VGND VPWR VPWR sky130_fd_sc_hd__decap_3
X_5258_ _5258_/A0 _4945_/X _5274_/S VGND VGND VPWR VPWR _7201_/D sky130_fd_sc_hd__mux2_2
XTAP_TAPCELL_ROW_3_300 VGND VPWR sky130_fd_sc_hd__tapvpwrvgnd_1
XFILLER_96_690 VGND VGND VPWR VPWR sky130_fd_sc_hd__decap_3
X_4209_ _4633_/A _4903_/A _4845_/A _4890_/B VGND VGND VPWR VPWR _4384_/A sky130_fd_sc_hd__and4_2
XFILLER_113_44 VGND VGND VPWR VPWR sky130_fd_sc_hd__decap_3
XFILLER_28_256 VGND VGND VPWR VPWR sky130_fd_sc_hd__fill_2
XTAP_TAPCELL_ROW_39_741 VGND VPWR sky130_fd_sc_hd__tapvpwrvgnd_1
XFILLER_113_66 VGND VGND VPWR VPWR sky130_fd_sc_hd__decap_3
XFILLER_43_259 VGND VGND VPWR VPWR sky130_fd_sc_hd__decap_3
XFILLER_73_48 VGND VGND VPWR VPWR sky130_fd_sc_hd__decap_3
XFILLER_12_613 VGND VGND VPWR VPWR sky130_fd_sc_hd__decap_3
XTAP_TAPCELL_ROW_104_1555 VGND VPWR sky130_fd_sc_hd__tapvpwrvgnd_1
XFILLER_24_473 VGND VGND VPWR VPWR sky130_fd_sc_hd__decap_3
XFILLER_24_495 VGND VGND VPWR VPWR sky130_fd_sc_hd__decap_3
XFILLER_51_281 VGND VGND VPWR VPWR sky130_fd_sc_hd__decap_3
XFILLER_12_657 VGND VGND VPWR VPWR sky130_fd_sc_hd__decap_3
XFILLER_8_628 VGND VGND VPWR VPWR sky130_fd_sc_hd__decap_3
XFILLER_11_167 VGND VGND VPWR VPWR sky130_fd_sc_hd__fill_1
XFILLER_7_116 VGND VGND VPWR VPWR sky130_fd_sc_hd__fill_1
XFILLER_7_138 VGND VGND VPWR VPWR sky130_fd_sc_hd__decap_3
XFILLER_20_690 VGND VGND VPWR VPWR sky130_fd_sc_hd__decap_3
XFILLER_22_74 VGND VGND VPWR VPWR sky130_fd_sc_hd__fill_1
XFILLER_22_85 VGND VGND VPWR VPWR sky130_fd_sc_hd__decap_3
XTAP_TAPCELL_ROW_59_1001 VGND VPWR sky130_fd_sc_hd__tapvpwrvgnd_1
XFILLER_98_23 VGND VGND VPWR VPWR sky130_fd_sc_hd__decap_3
XFILLER_3_322 VGND VGND VPWR VPWR sky130_fd_sc_hd__decap_3
XFILLER_112_209 VGND VGND VPWR VPWR sky130_fd_sc_hd__fill_1
XFILLER_3_355 VGND VGND VPWR VPWR sky130_fd_sc_hd__decap_3
XTAP_TAPCELL_ROW_115_1695 VGND VPWR sky130_fd_sc_hd__tapvpwrvgnd_1
XFILLER_78_112 VGND VGND VPWR VPWR sky130_fd_sc_hd__decap_3
XFILLER_79_635 VGND VGND VPWR VPWR sky130_fd_sc_hd__decap_3
XFILLER_79_668 VGND VGND VPWR VPWR sky130_fd_sc_hd__decap_3
XFILLER_66_318 VGND VGND VPWR VPWR sky130_fd_sc_hd__decap_3
XFILLER_78_178 VGND VGND VPWR VPWR sky130_fd_sc_hd__decap_3
XFILLER_79_679 VGND VGND VPWR VPWR sky130_fd_sc_hd__decap_3
XFILLER_94_616 VGND VGND VPWR VPWR sky130_fd_sc_hd__decap_3
XFILLER_19_223 VGND VGND VPWR VPWR sky130_fd_sc_hd__fill_1
XFILLER_93_137 VGND VGND VPWR VPWR sky130_fd_sc_hd__decap_3
XFILLER_19_234 VGND VGND VPWR VPWR sky130_fd_sc_hd__fill_1
XFILLER_19_256 VGND VGND VPWR VPWR sky130_fd_sc_hd__decap_3
XFILLER_47_543 VGND VGND VPWR VPWR sky130_fd_sc_hd__fill_1
XFILLER_74_351 VGND VGND VPWR VPWR sky130_fd_sc_hd__fill_2
XFILLER_93_159 VGND VGND VPWR VPWR sky130_fd_sc_hd__decap_3
XFILLER_47_598 VGND VGND VPWR VPWR sky130_fd_sc_hd__decap_3
XFILLER_34_226 VGND VGND VPWR VPWR sky130_fd_sc_hd__decap_3
XFILLER_62_557 VGND VGND VPWR VPWR sky130_fd_sc_hd__decap_3
XFILLER_15_440 VGND VGND VPWR VPWR sky130_fd_sc_hd__decap_3
XFILLER_34_259 VGND VGND VPWR VPWR sky130_fd_sc_hd__decap_3
XTAP_TAPCELL_ROW_17_468 VGND VPWR sky130_fd_sc_hd__tapvpwrvgnd_1
XFILLER_15_473 VGND VGND VPWR VPWR sky130_fd_sc_hd__decap_3
XFILLER_15_495 VGND VGND VPWR VPWR sky130_fd_sc_hd__fill_1
XFILLER_30_410 VGND VGND VPWR VPWR sky130_fd_sc_hd__decap_3
XFILLER_30_421 VGND VGND VPWR VPWR sky130_fd_sc_hd__decap_3
XFILLER_42_281 VGND VGND VPWR VPWR sky130_fd_sc_hd__decap_3
XFILLER_30_498 VGND VGND VPWR VPWR sky130_fd_sc_hd__fill_1
XFILLER_116_504 VGND VGND VPWR VPWR sky130_fd_sc_hd__decap_3
XFILLER_7_650 VGND VGND VPWR VPWR sky130_fd_sc_hd__decap_3
XFILLER_7_694 VGND VGND VPWR VPWR sky130_fd_sc_hd__decap_3
X_4491_ _7334_/Q _7302_/Q _4497_/S VGND VGND VPWR VPWR _7334_/D sky130_fd_sc_hd__mux2_2
XFILLER_116_559 VGND VGND VPWR VPWR sky130_fd_sc_hd__decap_3
X_3442_ _3442_/A _3442_/B VGND VGND VPWR VPWR _4394_/A sky130_fd_sc_hd__nand2_2
XFILLER_112_710 VGND VGND VPWR VPWR sky130_fd_sc_hd__decap_3
X_3373_ _3560_/B _3370_/Y _3566_/A2 VGND VGND VPWR VPWR _3429_/A sky130_fd_sc_hd__a21o_2
XFILLER_97_443 VGND VGND VPWR VPWR sky130_fd_sc_hd__decap_3
X_5112_ _4292_/A _3594_/B _4295_/X VGND VGND VPWR VPWR _5113_/B sky130_fd_sc_hd__a21oi_2
XFILLER_111_231 VGND VGND VPWR VPWR sky130_fd_sc_hd__decap_3
XFILLER_111_253 VGND VGND VPWR VPWR sky130_fd_sc_hd__decap_3
XFILLER_69_167 VGND VGND VPWR VPWR sky130_fd_sc_hd__fill_1
XFILLER_97_465 VGND VGND VPWR VPWR sky130_fd_sc_hd__decap_3
Xhold1306 _7232_/Q VGND VGND VPWR VPWR _5192_/A sky130_fd_sc_hd__dlygate4sd3_1
XTAP_TAPCELL_ROW_90_1389 VGND VPWR sky130_fd_sc_hd__tapvpwrvgnd_1
XTAP_TAPCELL_ROW_90_1378 VGND VPWR sky130_fd_sc_hd__tapvpwrvgnd_1
XFILLER_69_178 VGND VGND VPWR VPWR sky130_fd_sc_hd__decap_3
XFILLER_69_189 VGND VGND VPWR VPWR sky130_fd_sc_hd__decap_3
XFILLER_78_690 VGND VGND VPWR VPWR sky130_fd_sc_hd__decap_3
XFILLER_84_115 VGND VGND VPWR VPWR sky130_fd_sc_hd__decap_3
XFILLER_85_638 VGND VGND VPWR VPWR sky130_fd_sc_hd__decap_3
Xhold1317 _7305_/Q VGND VGND VPWR VPWR _4550_/A sky130_fd_sc_hd__dlygate4sd3_1
X_5043_ _6988_/Q _5066_/A VGND VGND VPWR VPWR _5044_/B sky130_fd_sc_hd__nor2_2
XFILLER_38_543 VGND VGND VPWR VPWR sky130_fd_sc_hd__fill_1
XFILLER_65_340 VGND VGND VPWR VPWR sky130_fd_sc_hd__fill_1
XFILLER_38_598 VGND VGND VPWR VPWR sky130_fd_sc_hd__decap_3
XFILLER_53_524 VGND VGND VPWR VPWR sky130_fd_sc_hd__decap_3
XFILLER_65_351 VGND VGND VPWR VPWR sky130_fd_sc_hd__fill_1
XFILLER_93_671 VGND VGND VPWR VPWR sky130_fd_sc_hd__fill_1
XFILLER_93_682 VGND VGND VPWR VPWR sky130_fd_sc_hd__decap_3
XTAP_TAPCELL_ROW_36_711 VGND VPWR sky130_fd_sc_hd__tapvpwrvgnd_1
XFILLER_80_321 VGND VGND VPWR VPWR sky130_fd_sc_hd__decap_3
XFILLER_80_343 VGND VGND VPWR VPWR sky130_fd_sc_hd__decap_3
X_6994_ _7396_/CLK _6994_/D _6274_/Y VGND VGND VPWR VPWR _6994_/Q sky130_fd_sc_hd__dfrtp_2
XFILLER_80_365 VGND VGND VPWR VPWR sky130_fd_sc_hd__decap_3
XFILLER_33_281 VGND VGND VPWR VPWR sky130_fd_sc_hd__decap_3
XFILLER_40_218 VGND VGND VPWR VPWR sky130_fd_sc_hd__decap_3
XFILLER_21_443 VGND VGND VPWR VPWR sky130_fd_sc_hd__decap_3
X_4827_ _4827_/A _4827_/B VGND VGND VPWR VPWR _4827_/X sky130_fd_sc_hd__xor2_2
XFILLER_21_498 VGND VGND VPWR VPWR sky130_fd_sc_hd__decap_3
XFILLER_5_609 VGND VGND VPWR VPWR sky130_fd_sc_hd__decap_3
X_4758_ _7004_/Q _4804_/A VGND VGND VPWR VPWR _4777_/B sky130_fd_sc_hd__nand2_2
X_4689_ _7002_/Q _4834_/A _4688_/X _7003_/Q VGND VGND VPWR VPWR _4804_/A sky130_fd_sc_hd__o211a_2
X_3709_ _3682_/A _3708_/X _4791_/A1 VGND VGND VPWR VPWR _3709_/X sky130_fd_sc_hd__a21o_2
XFILLER_107_548 VGND VGND VPWR VPWR sky130_fd_sc_hd__decap_3
XFILLER_108_44 VGND VGND VPWR VPWR sky130_fd_sc_hd__decap_3
X_6428_ _6557_/A VGND VGND VPWR VPWR _6428_/Y sky130_fd_sc_hd__inv_2
XFILLER_108_77 VGND VGND VPWR VPWR sky130_fd_sc_hd__fill_2
XFILLER_88_410 VGND VGND VPWR VPWR sky130_fd_sc_hd__decap_3
XFILLER_108_99 VGND VGND VPWR VPWR sky130_fd_sc_hd__decap_3
XFILLER_115_581 VGND VGND VPWR VPWR sky130_fd_sc_hd__decap_3
XFILLER_68_48 VGND VGND VPWR VPWR sky130_fd_sc_hd__fill_2
XFILLER_88_421 VGND VGND VPWR VPWR sky130_fd_sc_hd__decap_3
X_6359_ _6554_/A VGND VGND VPWR VPWR _6359_/Y sky130_fd_sc_hd__inv_2
XFILLER_102_242 VGND VGND VPWR VPWR sky130_fd_sc_hd__fill_2
XFILLER_102_253 VGND VGND VPWR VPWR sky130_fd_sc_hd__decap_3
XFILLER_102_286 VGND VGND VPWR VPWR sky130_fd_sc_hd__decap_3
XFILLER_75_126 VGND VGND VPWR VPWR sky130_fd_sc_hd__decap_3
XFILLER_76_627 VGND VGND VPWR VPWR sky130_fd_sc_hd__decap_3
XFILLER_88_498 VGND VGND VPWR VPWR sky130_fd_sc_hd__decap_3
XFILLER_75_159 VGND VGND VPWR VPWR sky130_fd_sc_hd__decap_3
XFILLER_29_576 VGND VGND VPWR VPWR sky130_fd_sc_hd__decap_3
XFILLER_56_373 VGND VGND VPWR VPWR sky130_fd_sc_hd__decap_3
XFILLER_84_660 VGND VGND VPWR VPWR sky130_fd_sc_hd__decap_3
XFILLER_90_118 VGND VGND VPWR VPWR sky130_fd_sc_hd__decap_3
XFILLER_90_129 VGND VGND VPWR VPWR sky130_fd_sc_hd__decap_3
XFILLER_17_63 VGND VGND VPWR VPWR sky130_fd_sc_hd__fill_1
XFILLER_83_181 VGND VGND VPWR VPWR sky130_fd_sc_hd__decap_3
XFILLER_84_693 VGND VGND VPWR VPWR sky130_fd_sc_hd__decap_3
XFILLER_16_259 VGND VGND VPWR VPWR sky130_fd_sc_hd__decap_3
XFILLER_12_421 VGND VGND VPWR VPWR sky130_fd_sc_hd__decap_3
XTAP_TAPCELL_ROW_65_1071 VGND VPWR sky130_fd_sc_hd__tapvpwrvgnd_1
XTAP_TAPCELL_ROW_14_427 VGND VPWR sky130_fd_sc_hd__tapvpwrvgnd_1
XTAP_TAPCELL_ROW_14_438 VGND VPWR sky130_fd_sc_hd__tapvpwrvgnd_1
XFILLER_33_84 VGND VGND VPWR VPWR sky130_fd_sc_hd__fill_2
XFILLER_12_498 VGND VGND VPWR VPWR sky130_fd_sc_hd__fill_2
XFILLER_8_469 VGND VGND VPWR VPWR sky130_fd_sc_hd__decap_3
XTAP_TAPCELL_ROW_117_1724 VGND VPWR sky130_fd_sc_hd__tapvpwrvgnd_1
XFILLER_4_620 VGND VGND VPWR VPWR sky130_fd_sc_hd__decap_3
XFILLER_4_675 VGND VGND VPWR VPWR sky130_fd_sc_hd__decap_3
XFILLER_98_207 VGND VGND VPWR VPWR sky130_fd_sc_hd__decap_3
XFILLER_106_592 VGND VGND VPWR VPWR sky130_fd_sc_hd__decap_3
XFILLER_66_104 VGND VGND VPWR VPWR sky130_fd_sc_hd__decap_3
XFILLER_67_638 VGND VGND VPWR VPWR sky130_fd_sc_hd__decap_3
XFILLER_94_424 VGND VGND VPWR VPWR sky130_fd_sc_hd__decap_3
XFILLER_82_619 VGND VGND VPWR VPWR sky130_fd_sc_hd__decap_3
XFILLER_94_446 VGND VGND VPWR VPWR sky130_fd_sc_hd__decap_3
XFILLER_75_671 VGND VGND VPWR VPWR sky130_fd_sc_hd__fill_1
XFILLER_75_682 VGND VGND VPWR VPWR sky130_fd_sc_hd__decap_3
XFILLER_74_192 VGND VGND VPWR VPWR sky130_fd_sc_hd__decap_3
XFILLER_35_579 VGND VGND VPWR VPWR sky130_fd_sc_hd__decap_3
XFILLER_50_516 VGND VGND VPWR VPWR sky130_fd_sc_hd__decap_3
XFILLER_74_80 VGND VGND VPWR VPWR sky130_fd_sc_hd__decap_3
XFILLER_74_91 VGND VGND VPWR VPWR sky130_fd_sc_hd__decap_3
XFILLER_90_663 VGND VGND VPWR VPWR sky130_fd_sc_hd__decap_3
X_3991_ _3991_/A _3991_/B VGND VGND VPWR VPWR _3991_/X sky130_fd_sc_hd__or2_2
XFILLER_90_696 VGND VGND VPWR VPWR sky130_fd_sc_hd__decap_3
XFILLER_15_281 VGND VGND VPWR VPWR sky130_fd_sc_hd__decap_3
X_7400_ _7400_/CLK _7400_/D _6680_/Y VGND VGND VPWR VPWR _7400_/Q sky130_fd_sc_hd__dfrtp_2
X_5661_ _5661_/A _5661_/B _5661_/C _5661_/D VGND VGND VPWR VPWR _5661_/X sky130_fd_sc_hd__and4_2
XFILLER_30_284 VGND VGND VPWR VPWR sky130_fd_sc_hd__fill_1
XFILLER_30_295 VGND VGND VPWR VPWR sky130_fd_sc_hd__decap_3
X_4612_ _4612_/A _4612_/B VGND VGND VPWR VPWR _5114_/B sky130_fd_sc_hd__nor2_2
X_7331_ _7342_/CLK _7331_/D _6611_/Y VGND VGND VPWR VPWR _7331_/Q sky130_fd_sc_hd__dfrtp_2
XFILLER_116_334 VGND VGND VPWR VPWR sky130_fd_sc_hd__decap_3
X_7262_ _7358_/CLK _7262_/D _6542_/Y VGND VGND VPWR VPWR _7262_/Q sky130_fd_sc_hd__dfrtp_2
XTAP_TAPCELL_ROW_92_1407 VGND VPWR sky130_fd_sc_hd__tapvpwrvgnd_1
XFILLER_116_378 VGND VGND VPWR VPWR sky130_fd_sc_hd__decap_3
XFILLER_89_218 VGND VGND VPWR VPWR sky130_fd_sc_hd__decap_3
X_4474_ _4474_/A0 _7310_/Q _4497_/S VGND VGND VPWR VPWR _7342_/D sky130_fd_sc_hd__mux2_2
X_7193_ _7358_/CLK _7193_/D _6473_/Y VGND VGND VPWR VPWR _7193_/Q sky130_fd_sc_hd__dfrtp_2
X_3425_ _3589_/A _3591_/A _3589_/B _3590_/C VGND VGND VPWR VPWR _3527_/A sky130_fd_sc_hd__o31a_2
XFILLER_58_616 VGND VGND VPWR VPWR sky130_fd_sc_hd__decap_3
XFILLER_85_402 VGND VGND VPWR VPWR sky130_fd_sc_hd__decap_3
X_3356_ _5118_/D _3354_/X _3355_/Y _5129_/A VGND VGND VPWR VPWR _4537_/B sky130_fd_sc_hd__a22o_2
XFILLER_100_713 VGND VGND VPWR VPWR sky130_fd_sc_hd__fill_1
XFILLER_112_595 VGND VGND VPWR VPWR sky130_fd_sc_hd__decap_3
XFILLER_38_29 VGND VGND VPWR VPWR sky130_fd_sc_hd__decap_3
XFILLER_85_435 VGND VGND VPWR VPWR sky130_fd_sc_hd__decap_3
XFILLER_97_284 VGND VGND VPWR VPWR sky130_fd_sc_hd__decap_3
Xhold1103 _7325_/Q VGND VGND VPWR VPWR _4509_/A1 sky130_fd_sc_hd__dlygate4sd3_1
Xhold1114 _7240_/Q VGND VGND VPWR VPWR _5175_/A sky130_fd_sc_hd__dlygate4sd3_1
Xhold1125 _7273_/Q VGND VGND VPWR VPWR _4807_/A0 sky130_fd_sc_hd__dlygate4sd3_1
Xhold1136 _7016_/Q VGND VGND VPWR VPWR _5624_/A sky130_fd_sc_hd__dlygate4sd3_1
Xhold1147 _7015_/Q VGND VGND VPWR VPWR _5626_/A sky130_fd_sc_hd__dlygate4sd3_1
Xhold1158 _7288_/Q VGND VGND VPWR VPWR _4585_/A sky130_fd_sc_hd__dlygate4sd3_1
X_5026_ _5026_/A _5026_/B VGND VGND VPWR VPWR _6990_/D sky130_fd_sc_hd__nor2_2
XFILLER_26_513 VGND VGND VPWR VPWR sky130_fd_sc_hd__fill_1
XFILLER_66_660 VGND VGND VPWR VPWR sky130_fd_sc_hd__decap_3
XFILLER_72_118 VGND VGND VPWR VPWR sky130_fd_sc_hd__fill_1
Xhold1169 _7333_/Q VGND VGND VPWR VPWR _4493_/A0 sky130_fd_sc_hd__dlygate4sd3_1
XFILLER_66_693 VGND VGND VPWR VPWR sky130_fd_sc_hd__decap_3
XFILLER_72_129 VGND VGND VPWR VPWR sky130_fd_sc_hd__decap_3
XFILLER_81_641 VGND VGND VPWR VPWR sky130_fd_sc_hd__decap_3
XFILLER_26_557 VGND VGND VPWR VPWR sky130_fd_sc_hd__decap_3
XFILLER_41_505 VGND VGND VPWR VPWR sky130_fd_sc_hd__decap_3
X_6977_ _6983_/CLK _6977_/D VGND VGND VPWR VPWR _6977_/Q sky130_fd_sc_hd__dfxtp_2
XFILLER_110_23 VGND VGND VPWR VPWR sky130_fd_sc_hd__decap_3
XFILLER_53_387 VGND VGND VPWR VPWR sky130_fd_sc_hd__decap_3
XFILLER_81_685 VGND VGND VPWR VPWR sky130_fd_sc_hd__decap_3
XFILLER_110_56 VGND VGND VPWR VPWR sky130_fd_sc_hd__decap_3
XFILLER_80_195 VGND VGND VPWR VPWR sky130_fd_sc_hd__fill_1
XTAP_TAPCELL_ROW_101_1525 VGND VPWR sky130_fd_sc_hd__tapvpwrvgnd_1
XFILLER_21_251 VGND VGND VPWR VPWR sky130_fd_sc_hd__decap_3
XFILLER_119_150 VGND VGND VPWR VPWR sky130_fd_sc_hd__fill_2
XFILLER_119_172 VGND VGND VPWR VPWR sky130_fd_sc_hd__decap_3
XFILLER_119_21 VGND VGND VPWR VPWR sky130_fd_sc_hd__decap_3
XFILLER_119_32 VGND VGND VPWR VPWR sky130_fd_sc_hd__fill_2
XFILLER_119_54 VGND VGND VPWR VPWR sky130_fd_sc_hd__fill_2
XFILLER_107_367 VGND VGND VPWR VPWR sky130_fd_sc_hd__decap_3
XFILLER_1_612 VGND VGND VPWR VPWR sky130_fd_sc_hd__decap_3
XFILLER_1_623 VGND VGND VPWR VPWR sky130_fd_sc_hd__decap_3
Xhold970 _7095_/Q VGND VGND VPWR VPWR _7095_/D sky130_fd_sc_hd__dlygate4sd3_1
Xhold981 _7072_/Q VGND VGND VPWR VPWR _7072_/D sky130_fd_sc_hd__dlygate4sd3_1
XFILLER_0_144 VGND VGND VPWR VPWR sky130_fd_sc_hd__fill_2
XFILLER_1_656 VGND VGND VPWR VPWR sky130_fd_sc_hd__decap_3
XFILLER_49_605 VGND VGND VPWR VPWR sky130_fd_sc_hd__decap_3
XFILLER_88_251 VGND VGND VPWR VPWR sky130_fd_sc_hd__fill_1
Xhold992 _7059_/Q VGND VGND VPWR VPWR _7059_/D sky130_fd_sc_hd__dlygate4sd3_1
XTAP_TAPCELL_ROW_112_1654 VGND VPWR sky130_fd_sc_hd__tapvpwrvgnd_1
XFILLER_0_166 VGND VGND VPWR VPWR sky130_fd_sc_hd__fill_2
XFILLER_48_115 VGND VGND VPWR VPWR sky130_fd_sc_hd__decap_3
XFILLER_49_638 VGND VGND VPWR VPWR sky130_fd_sc_hd__decap_3
XFILLER_76_435 VGND VGND VPWR VPWR sky130_fd_sc_hd__decap_3
XFILLER_88_262 VGND VGND VPWR VPWR sky130_fd_sc_hd__decap_3
XFILLER_95_46 VGND VGND VPWR VPWR sky130_fd_sc_hd__decap_3
XFILLER_95_57 VGND VGND VPWR VPWR sky130_fd_sc_hd__decap_3
XFILLER_76_468 VGND VGND VPWR VPWR sky130_fd_sc_hd__decap_3
XFILLER_88_295 VGND VGND VPWR VPWR sky130_fd_sc_hd__decap_3
XFILLER_28_62 VGND VGND VPWR VPWR sky130_fd_sc_hd__decap_3
XFILLER_29_340 VGND VGND VPWR VPWR sky130_fd_sc_hd__decap_3
XFILLER_29_373 VGND VGND VPWR VPWR sky130_fd_sc_hd__decap_3
XFILLER_57_671 VGND VGND VPWR VPWR sky130_fd_sc_hd__fill_1
XFILLER_57_682 VGND VGND VPWR VPWR sky130_fd_sc_hd__decap_3
XFILLER_64_619 VGND VGND VPWR VPWR sky130_fd_sc_hd__decap_3
XFILLER_91_427 VGND VGND VPWR VPWR sky130_fd_sc_hd__decap_3
XTAP_TAPCELL_ROW_67_1100 VGND VPWR sky130_fd_sc_hd__tapvpwrvgnd_1
XFILLER_56_181 VGND VGND VPWR VPWR sky130_fd_sc_hd__decap_3
XFILLER_91_449 VGND VGND VPWR VPWR sky130_fd_sc_hd__decap_3
XFILLER_44_343 VGND VGND VPWR VPWR sky130_fd_sc_hd__decap_3
XFILLER_72_663 VGND VGND VPWR VPWR sky130_fd_sc_hd__decap_3
XFILLER_71_162 VGND VGND VPWR VPWR sky130_fd_sc_hd__decap_3
XFILLER_71_184 VGND VGND VPWR VPWR sky130_fd_sc_hd__decap_3
XFILLER_72_696 VGND VGND VPWR VPWR sky130_fd_sc_hd__decap_3
XTAP_TAPCELL_ROW_27_596 VGND VPWR sky130_fd_sc_hd__tapvpwrvgnd_1
XFILLER_44_94 VGND VGND VPWR VPWR sky130_fd_sc_hd__decap_3
XFILLER_40_560 VGND VGND VPWR VPWR sky130_fd_sc_hd__decap_3
XFILLER_9_712 VGND VGND VPWR VPWR sky130_fd_sc_hd__fill_2
XFILLER_8_299 VGND VGND VPWR VPWR sky130_fd_sc_hd__decap_3
XFILLER_5_55 VGND VGND VPWR VPWR sky130_fd_sc_hd__fill_1
XFILLER_99_505 VGND VGND VPWR VPWR sky130_fd_sc_hd__decap_3
XFILLER_113_315 VGND VGND VPWR VPWR sky130_fd_sc_hd__decap_3
XFILLER_113_337 VGND VGND VPWR VPWR sky130_fd_sc_hd__decap_3
XFILLER_4_483 VGND VGND VPWR VPWR sky130_fd_sc_hd__decap_3
XFILLER_99_538 VGND VGND VPWR VPWR sky130_fd_sc_hd__decap_3
XFILLER_79_240 VGND VGND VPWR VPWR sky130_fd_sc_hd__decap_3
XFILLER_95_700 VGND VGND VPWR VPWR sky130_fd_sc_hd__decap_3
X_4190_ _7263_/Q _4422_/A2 _4263_/A2 _7135_/Q _4189_/X VGND VGND VPWR VPWR _4637_/B
+ sky130_fd_sc_hd__a221o_2
XFILLER_79_284 VGND VGND VPWR VPWR sky130_fd_sc_hd__decap_3
XFILLER_67_435 VGND VGND VPWR VPWR sky130_fd_sc_hd__decap_3
XFILLER_67_446 VGND VGND VPWR VPWR sky130_fd_sc_hd__fill_2
XFILLER_48_660 VGND VGND VPWR VPWR sky130_fd_sc_hd__decap_3
XFILLER_67_479 VGND VGND VPWR VPWR sky130_fd_sc_hd__fill_2
XFILLER_94_287 VGND VGND VPWR VPWR sky130_fd_sc_hd__decap_3
XFILLER_47_181 VGND VGND VPWR VPWR sky130_fd_sc_hd__decap_3
XFILLER_48_693 VGND VGND VPWR VPWR sky130_fd_sc_hd__decap_3
XFILLER_54_129 VGND VGND VPWR VPWR sky130_fd_sc_hd__decap_3
XFILLER_63_641 VGND VGND VPWR VPWR sky130_fd_sc_hd__decap_3
XFILLER_82_438 VGND VGND VPWR VPWR sky130_fd_sc_hd__fill_2
XFILLER_85_90 VGND VGND VPWR VPWR sky130_fd_sc_hd__decap_3
X_6900_ clkload9/A _6900_/D VGND VGND VPWR VPWR _6900_/Q sky130_fd_sc_hd__dfxtp_2
XFILLER_23_505 VGND VGND VPWR VPWR sky130_fd_sc_hd__decap_3
X_6831_ clkload6/A _6831_/D VGND VGND VPWR VPWR _6831_/Q sky130_fd_sc_hd__dfxtp_2
XFILLER_23_527 VGND VGND VPWR VPWR sky130_fd_sc_hd__decap_3
XFILLER_63_685 VGND VGND VPWR VPWR sky130_fd_sc_hd__decap_3
X_6762_ _6906_/CLK _6762_/D VGND VGND VPWR VPWR _6762_/Q sky130_fd_sc_hd__dfxtp_2
XFILLER_31_571 VGND VGND VPWR VPWR sky130_fd_sc_hd__decap_3
XFILLER_50_368 VGND VGND VPWR VPWR sky130_fd_sc_hd__fill_1
X_6693_ _6983_/CLK _6693_/D VGND VGND VPWR VPWR _6693_/Q sky130_fd_sc_hd__dfxtp_2
X_5644_ _3371_/A _5130_/C _3340_/B _3327_/B VGND VGND VPWR VPWR _5644_/X sky130_fd_sc_hd__o211a_2
XFILLER_117_632 VGND VGND VPWR VPWR sky130_fd_sc_hd__decap_3
X_7314_ _7355_/CLK _7314_/D _6594_/Y VGND VGND VPWR VPWR _7314_/Q sky130_fd_sc_hd__dfrtp_2
X_5575_ _5575_/A1 _4960_/A _5010_/D VGND VGND VPWR VPWR _7042_/D sky130_fd_sc_hd__a21o_2
XFILLER_117_665 VGND VGND VPWR VPWR sky130_fd_sc_hd__decap_3
XFILLER_117_676 VGND VGND VPWR VPWR sky130_fd_sc_hd__decap_3
X_4526_ _4526_/A0 _7284_/Q _4528_/B VGND VGND VPWR VPWR _7316_/D sky130_fd_sc_hd__mux2_2
XFILLER_116_186 VGND VGND VPWR VPWR sky130_fd_sc_hd__decap_3
XFILLER_116_197 VGND VGND VPWR VPWR sky130_fd_sc_hd__decap_3
XFILLER_49_17 VGND VGND VPWR VPWR sky130_fd_sc_hd__fill_1
X_7245_ _7374_/CLK _7245_/D _6525_/Y VGND VGND VPWR VPWR _7245_/Q sky130_fd_sc_hd__dfrtp_2
X_4457_ _4720_/A _4720_/B _4456_/X VGND VGND VPWR VPWR _4457_/X sky130_fd_sc_hd__o21a_2
XFILLER_104_348 VGND VGND VPWR VPWR sky130_fd_sc_hd__fill_1
XFILLER_98_560 VGND VGND VPWR VPWR sky130_fd_sc_hd__decap_3
X_7176_ _7374_/CLK _7176_/D _6456_/Y VGND VGND VPWR VPWR _7176_/Q sky130_fd_sc_hd__dfrtp_2
XFILLER_105_12 VGND VGND VPWR VPWR sky130_fd_sc_hd__decap_3
XFILLER_85_210 VGND VGND VPWR VPWR sky130_fd_sc_hd__decap_3
XFILLER_98_582 VGND VGND VPWR VPWR sky130_fd_sc_hd__decap_3
X_4388_ _7273_/Q _4437_/A2 _4385_/X _4387_/X VGND VGND VPWR VPWR _4388_/X sky130_fd_sc_hd__a211o_2
XFILLER_58_457 VGND VGND VPWR VPWR sky130_fd_sc_hd__decap_3
XFILLER_85_243 VGND VGND VPWR VPWR sky130_fd_sc_hd__decap_3
X_3339_ _3319_/X _5238_/B _3329_/Y _3339_/C1 VGND VGND VPWR VPWR _3469_/A sky130_fd_sc_hd__a211oi_4
XFILLER_105_89 VGND VGND VPWR VPWR sky130_fd_sc_hd__decap_3
XFILLER_39_671 VGND VGND VPWR VPWR sky130_fd_sc_hd__fill_1
XFILLER_46_619 VGND VGND VPWR VPWR sky130_fd_sc_hd__decap_3
XFILLER_38_170 VGND VGND VPWR VPWR sky130_fd_sc_hd__decap_3
XFILLER_39_682 VGND VGND VPWR VPWR sky130_fd_sc_hd__decap_3
XFILLER_54_630 VGND VGND VPWR VPWR sky130_fd_sc_hd__decap_3
XFILLER_73_449 VGND VGND VPWR VPWR sky130_fd_sc_hd__decap_3
XFILLER_85_287 VGND VGND VPWR VPWR sky130_fd_sc_hd__decap_3
X_5009_ _5009_/A _5009_/B VGND VGND VPWR VPWR _5010_/D sky130_fd_sc_hd__nor2_2
XFILLER_26_332 VGND VGND VPWR VPWR sky130_fd_sc_hd__decap_3
XFILLER_54_663 VGND VGND VPWR VPWR sky130_fd_sc_hd__decap_3
XTAP_TAPCELL_ROW_44_809 VGND VPWR sky130_fd_sc_hd__tapvpwrvgnd_1
XFILLER_14_527 VGND VGND VPWR VPWR sky130_fd_sc_hd__decap_3
XFILLER_14_538 VGND VGND VPWR VPWR sky130_fd_sc_hd__decap_3
XFILLER_41_302 VGND VGND VPWR VPWR sky130_fd_sc_hd__decap_3
XFILLER_54_696 VGND VGND VPWR VPWR sky130_fd_sc_hd__decap_3
XFILLER_41_346 VGND VGND VPWR VPWR sky130_fd_sc_hd__decap_3
XTAP_TAPCELL_ROW_62_1030 VGND VPWR sky130_fd_sc_hd__tapvpwrvgnd_1
XTAP_TAPCELL_ROW_24_555 VGND VPWR sky130_fd_sc_hd__tapvpwrvgnd_1
XFILLER_22_582 VGND VGND VPWR VPWR sky130_fd_sc_hd__decap_3
XFILLER_108_610 VGND VGND VPWR VPWR sky130_fd_sc_hd__decap_3
XFILLER_14_97 VGND VGND VPWR VPWR sky130_fd_sc_hd__decap_3
XFILLER_5_203 VGND VGND VPWR VPWR sky130_fd_sc_hd__fill_1
XFILLER_6_704 VGND VGND VPWR VPWR sky130_fd_sc_hd__decap_3
XFILLER_108_643 VGND VGND VPWR VPWR sky130_fd_sc_hd__fill_1
XFILLER_108_654 VGND VGND VPWR VPWR sky130_fd_sc_hd__decap_3
XFILLER_107_131 VGND VGND VPWR VPWR sky130_fd_sc_hd__decap_3
XFILLER_107_164 VGND VGND VPWR VPWR sky130_fd_sc_hd__decap_3
XFILLER_108_687 VGND VGND VPWR VPWR sky130_fd_sc_hd__decap_3
XFILLER_30_63 VGND VGND VPWR VPWR sky130_fd_sc_hd__fill_2
XFILLER_107_175 VGND VGND VPWR VPWR sky130_fd_sc_hd__fill_2
XFILLER_30_85 VGND VGND VPWR VPWR sky130_fd_sc_hd__fill_1
XFILLER_77_700 VGND VGND VPWR VPWR sky130_fd_sc_hd__decap_3
XFILLER_96_519 VGND VGND VPWR VPWR sky130_fd_sc_hd__decap_3
XFILLER_110_318 VGND VGND VPWR VPWR sky130_fd_sc_hd__decap_3
XFILLER_1_475 VGND VGND VPWR VPWR sky130_fd_sc_hd__decap_3
XTAP_TAPCELL_ROW_73_1170 VGND VPWR sky130_fd_sc_hd__tapvpwrvgnd_1
XFILLER_49_457 VGND VGND VPWR VPWR sky130_fd_sc_hd__decap_3
XFILLER_76_210 VGND VGND VPWR VPWR sky130_fd_sc_hd__decap_3
XFILLER_76_243 VGND VGND VPWR VPWR sky130_fd_sc_hd__decap_3
XFILLER_37_608 VGND VGND VPWR VPWR sky130_fd_sc_hd__decap_3
XFILLER_49_468 VGND VGND VPWR VPWR sky130_fd_sc_hd__decap_3
XFILLER_91_202 VGND VGND VPWR VPWR sky130_fd_sc_hd__decap_3
XFILLER_29_181 VGND VGND VPWR VPWR sky130_fd_sc_hd__decap_3
XFILLER_76_298 VGND VGND VPWR VPWR sky130_fd_sc_hd__decap_3
XPHY_EDGE_ROW_101_Right_101 VGND VGND VPWR VPWR sky130_fd_sc_hd__decap_3
XFILLER_17_343 VGND VGND VPWR VPWR sky130_fd_sc_hd__decap_3
XFILLER_45_641 VGND VGND VPWR VPWR sky130_fd_sc_hd__decap_3
XFILLER_32_302 VGND VGND VPWR VPWR sky130_fd_sc_hd__decap_3
XFILLER_45_685 VGND VGND VPWR VPWR sky130_fd_sc_hd__decap_3
XFILLER_60_622 VGND VGND VPWR VPWR sky130_fd_sc_hd__decap_3
XFILLER_32_346 VGND VGND VPWR VPWR sky130_fd_sc_hd__decap_3
XFILLER_60_666 VGND VGND VPWR VPWR sky130_fd_sc_hd__decap_3
XFILLER_32_368 VGND VGND VPWR VPWR sky130_fd_sc_hd__fill_2
XFILLER_32_379 VGND VGND VPWR VPWR sky130_fd_sc_hd__decap_3
XFILLER_60_699 VGND VGND VPWR VPWR sky130_fd_sc_hd__fill_1
XFILLER_13_582 VGND VGND VPWR VPWR sky130_fd_sc_hd__decap_3
XFILLER_9_564 VGND VGND VPWR VPWR sky130_fd_sc_hd__decap_3
XFILLER_9_597 VGND VGND VPWR VPWR sky130_fd_sc_hd__decap_3
X_5360_ _5360_/A0 _4470_/X _5360_/S VGND VGND VPWR VPWR _7151_/D sky130_fd_sc_hd__mux2_2
XFILLER_114_613 VGND VGND VPWR VPWR sky130_fd_sc_hd__decap_3
X_4311_ _4311_/A _4311_/B _4311_/C VGND VGND VPWR VPWR _4311_/X sky130_fd_sc_hd__or3_2
XFILLER_113_134 VGND VGND VPWR VPWR sky130_fd_sc_hd__fill_1
XFILLER_114_657 VGND VGND VPWR VPWR sky130_fd_sc_hd__decap_3
XFILLER_4_280 VGND VGND VPWR VPWR sky130_fd_sc_hd__decap_3
XFILLER_4_291 VGND VGND VPWR VPWR sky130_fd_sc_hd__decap_3
XFILLER_87_508 VGND VGND VPWR VPWR sky130_fd_sc_hd__decap_3
X_7030_ _7313_/CLK _7030_/D _6310_/Y VGND VGND VPWR VPWR _7030_/Q sky130_fd_sc_hd__dfrtp_2
XFILLER_99_357 VGND VGND VPWR VPWR sky130_fd_sc_hd__fill_1
XFILLER_101_307 VGND VGND VPWR VPWR sky130_fd_sc_hd__decap_3
XFILLER_67_210 VGND VGND VPWR VPWR sky130_fd_sc_hd__decap_3
X_4173_ _7072_/Q VGND VGND VPWR VPWR _4173_/Y sky130_fd_sc_hd__inv_2
XFILLER_28_619 VGND VGND VPWR VPWR sky130_fd_sc_hd__decap_3
XFILLER_67_265 VGND VGND VPWR VPWR sky130_fd_sc_hd__decap_3
XFILLER_83_703 VGND VGND VPWR VPWR sky130_fd_sc_hd__decap_3
XFILLER_95_585 VGND VGND VPWR VPWR sky130_fd_sc_hd__decap_3
XFILLER_55_449 VGND VGND VPWR VPWR sky130_fd_sc_hd__decap_3
XFILLER_67_287 VGND VGND VPWR VPWR sky130_fd_sc_hd__decap_3
XFILLER_36_663 VGND VGND VPWR VPWR sky130_fd_sc_hd__decap_3
XFILLER_82_246 VGND VGND VPWR VPWR sky130_fd_sc_hd__decap_3
XFILLER_35_151 VGND VGND VPWR VPWR sky130_fd_sc_hd__decap_3
XFILLER_36_696 VGND VGND VPWR VPWR sky130_fd_sc_hd__decap_3
XFILLER_82_279 VGND VGND VPWR VPWR sky130_fd_sc_hd__decap_3
XFILLER_35_184 VGND VGND VPWR VPWR sky130_fd_sc_hd__decap_3
XFILLER_50_110 VGND VGND VPWR VPWR sky130_fd_sc_hd__fill_1
XFILLER_51_644 VGND VGND VPWR VPWR sky130_fd_sc_hd__decap_3
Xplace482 _3994_/S VGND VGND VPWR VPWR _3987_/S sky130_fd_sc_hd__buf_2
Xplace471 _3376_/Y VGND VGND VPWR VPWR _5161_/A sky130_fd_sc_hd__buf_2
Xplace460 _4244_/B VGND VGND VPWR VPWR _4488_/S sky130_fd_sc_hd__buf_2
X_6814_ _6968_/CLK _6814_/D VGND VGND VPWR VPWR _6814_/Q sky130_fd_sc_hd__dfxtp_2
XFILLER_51_688 VGND VGND VPWR VPWR sky130_fd_sc_hd__decap_3
Xplace493 _4857_/A VGND VGND VPWR VPWR _4777_/A sky130_fd_sc_hd__buf_2
X_6745_ clkload5/A _6745_/D VGND VGND VPWR VPWR _6745_/Q sky130_fd_sc_hd__dfxtp_2
XFILLER_50_176 VGND VGND VPWR VPWR sky130_fd_sc_hd__decap_3
XTAP_TAPCELL_ROW_21_525 VGND VPWR sky130_fd_sc_hd__tapvpwrvgnd_1
XFILLER_31_390 VGND VGND VPWR VPWR sky130_fd_sc_hd__fill_2
X_6676_ _6676_/A VGND VGND VPWR VPWR _6676_/Y sky130_fd_sc_hd__inv_2
X_3888_ _6844_/Q _3906_/A2 _3911_/B1 _6839_/Q VGND VGND VPWR VPWR _3888_/X sky130_fd_sc_hd__a22o_2
XTAP_TAPCELL_ROW_98_1479 VGND VPWR sky130_fd_sc_hd__tapvpwrvgnd_1
XFILLER_117_440 VGND VGND VPWR VPWR sky130_fd_sc_hd__fill_1
XFILLER_105_635 VGND VGND VPWR VPWR sky130_fd_sc_hd__decap_3
X_4509_ _4509_/A1 _3398_/Y _4244_/X VGND VGND VPWR VPWR _7325_/D sky130_fd_sc_hd__a21o_2
XFILLER_104_156 VGND VGND VPWR VPWR sky130_fd_sc_hd__decap_3
XFILLER_105_668 VGND VGND VPWR VPWR sky130_fd_sc_hd__decap_3
XFILLER_105_679 VGND VGND VPWR VPWR sky130_fd_sc_hd__decap_3
XFILLER_78_508 VGND VGND VPWR VPWR sky130_fd_sc_hd__decap_3
X_7228_ _7360_/CLK _7228_/D _6508_/Y VGND VGND VPWR VPWR _7228_/Q sky130_fd_sc_hd__dfrtp_2
XFILLER_104_189 VGND VGND VPWR VPWR sky130_fd_sc_hd__decap_3
XFILLER_116_44 VGND VGND VPWR VPWR sky130_fd_sc_hd__decap_3
XFILLER_59_700 VGND VGND VPWR VPWR sky130_fd_sc_hd__decap_3
XFILLER_76_15 VGND VGND VPWR VPWR sky130_fd_sc_hd__decap_3
XFILLER_116_77 VGND VGND VPWR VPWR sky130_fd_sc_hd__decap_3
XFILLER_116_88 VGND VGND VPWR VPWR sky130_fd_sc_hd__decap_3
XFILLER_58_221 VGND VGND VPWR VPWR sky130_fd_sc_hd__decap_3
X_7159_ _7357_/CLK _7159_/D _6439_/Y VGND VGND VPWR VPWR _7159_/Q sky130_fd_sc_hd__dfrtp_2
XFILLER_100_351 VGND VGND VPWR VPWR sky130_fd_sc_hd__decap_3
XFILLER_100_384 VGND VGND VPWR VPWR sky130_fd_sc_hd__decap_3
XFILLER_46_438 VGND VGND VPWR VPWR sky130_fd_sc_hd__decap_3
XTAP_TAPCELL_ROW_29_625 VGND VPWR sky130_fd_sc_hd__tapvpwrvgnd_1
XFILLER_27_641 VGND VGND VPWR VPWR sky130_fd_sc_hd__decap_3
XFILLER_73_268 VGND VGND VPWR VPWR sky130_fd_sc_hd__fill_1
Xclkbuf_leaf_38_clk clkload0/A VGND VGND VPWR VPWR _7388_/CLK sky130_fd_sc_hd__clkbuf_16
XTAP_TAPCELL_ROW_57_967 VGND VPWR sky130_fd_sc_hd__tapvpwrvgnd_1
XFILLER_27_685 VGND VGND VPWR VPWR sky130_fd_sc_hd__decap_3
XFILLER_42_600 VGND VGND VPWR VPWR sky130_fd_sc_hd__decap_3
XFILLER_54_460 VGND VGND VPWR VPWR sky130_fd_sc_hd__fill_1
XFILLER_92_69 VGND VGND VPWR VPWR sky130_fd_sc_hd__decap_3
XTAP_TAPCELL_ROW_1_272 VGND VPWR sky130_fd_sc_hd__tapvpwrvgnd_1
XFILLER_14_346 VGND VGND VPWR VPWR sky130_fd_sc_hd__decap_3
XFILLER_26_184 VGND VGND VPWR VPWR sky130_fd_sc_hd__decap_3
XFILLER_41_110 VGND VGND VPWR VPWR sky130_fd_sc_hd__fill_2
XFILLER_42_633 VGND VGND VPWR VPWR sky130_fd_sc_hd__decap_3
XTAP_TAPCELL_ROW_107_1597 VGND VPWR sky130_fd_sc_hd__tapvpwrvgnd_1
XFILLER_41_154 VGND VGND VPWR VPWR sky130_fd_sc_hd__decap_3
XFILLER_42_666 VGND VGND VPWR VPWR sky130_fd_sc_hd__decap_3
XFILLER_42_699 VGND VGND VPWR VPWR sky130_fd_sc_hd__fill_1
XFILLER_10_563 VGND VGND VPWR VPWR sky130_fd_sc_hd__decap_3
XFILLER_41_51 VGND VGND VPWR VPWR sky130_fd_sc_hd__decap_3
XFILLER_6_545 VGND VGND VPWR VPWR sky130_fd_sc_hd__decap_3
XFILLER_6_578 VGND VGND VPWR VPWR sky130_fd_sc_hd__decap_3
XFILLER_6_589 VGND VGND VPWR VPWR sky130_fd_sc_hd__decap_3
XFILLER_111_638 VGND VGND VPWR VPWR sky130_fd_sc_hd__decap_3
XTAP_TAPCELL_ROW_9_372 VGND VPWR sky130_fd_sc_hd__tapvpwrvgnd_1
XFILLER_104_690 VGND VGND VPWR VPWR sky130_fd_sc_hd__decap_3
XFILLER_110_115 VGND VGND VPWR VPWR sky130_fd_sc_hd__decap_3
XFILLER_49_210 VGND VGND VPWR VPWR sky130_fd_sc_hd__decap_3
XFILLER_65_703 VGND VGND VPWR VPWR sky130_fd_sc_hd__decap_3
XFILLER_37_438 VGND VGND VPWR VPWR sky130_fd_sc_hd__decap_3
XFILLER_37_449 VGND VGND VPWR VPWR sky130_fd_sc_hd__fill_2
XFILLER_49_287 VGND VGND VPWR VPWR sky130_fd_sc_hd__decap_3
XFILLER_64_213 VGND VGND VPWR VPWR sky130_fd_sc_hd__decap_3
XFILLER_66_70 VGND VGND VPWR VPWR sky130_fd_sc_hd__decap_3
XFILLER_92_533 VGND VGND VPWR VPWR sky130_fd_sc_hd__decap_3
XFILLER_18_663 VGND VGND VPWR VPWR sky130_fd_sc_hd__decap_3
XFILLER_64_246 VGND VGND VPWR VPWR sky130_fd_sc_hd__decap_3
Xclkbuf_leaf_29_clk clkload0/A VGND VGND VPWR VPWR _7354_/CLK sky130_fd_sc_hd__clkbuf_16
XFILLER_17_140 VGND VGND VPWR VPWR sky130_fd_sc_hd__decap_3
XFILLER_18_696 VGND VGND VPWR VPWR sky130_fd_sc_hd__decap_3
XFILLER_33_600 VGND VGND VPWR VPWR sky130_fd_sc_hd__decap_3
XFILLER_52_419 VGND VGND VPWR VPWR sky130_fd_sc_hd__fill_1
XFILLER_33_644 VGND VGND VPWR VPWR sky130_fd_sc_hd__decap_3
XFILLER_60_441 VGND VGND VPWR VPWR sky130_fd_sc_hd__decap_3
X_4860_ _4687_/B _4859_/Y _4777_/A VGND VGND VPWR VPWR _4860_/Y sky130_fd_sc_hd__o21ai_2
XFILLER_32_154 VGND VGND VPWR VPWR sky130_fd_sc_hd__decap_3
XFILLER_33_688 VGND VGND VPWR VPWR sky130_fd_sc_hd__decap_3
XFILLER_82_91 VGND VGND VPWR VPWR sky130_fd_sc_hd__decap_3
X_3811_ _3629_/A _3808_/X _3810_/X _3741_/X VGND VGND VPWR VPWR _3811_/X sky130_fd_sc_hd__a22o_2
XFILLER_20_327 VGND VGND VPWR VPWR sky130_fd_sc_hd__decap_3
X_6530_ _6635_/A VGND VGND VPWR VPWR _6530_/Y sky130_fd_sc_hd__inv_2
X_4791_ _4791_/A1 _5664_/A _3697_/Y _4791_/C1 VGND VGND VPWR VPWR _4791_/Y sky130_fd_sc_hd__a211oi_2
XFILLER_20_349 VGND VGND VPWR VPWR sky130_fd_sc_hd__fill_2
X_3742_ _6833_/Q _3890_/B1 _3850_/B1 _6843_/Q VGND VGND VPWR VPWR _3742_/X sky130_fd_sc_hd__a22o_2
X_6461_ _6652_/A VGND VGND VPWR VPWR _6461_/Y sky130_fd_sc_hd__inv_2
X_3673_ _6856_/Q _6864_/Q _6904_/Q _6912_/Q _3991_/B _3661_/B VGND VGND VPWR VPWR
+ _3673_/X sky130_fd_sc_hd__mux4_2
XFILLER_9_383 VGND VGND VPWR VPWR sky130_fd_sc_hd__decap_3
X_6392_ _6584_/A VGND VGND VPWR VPWR _6392_/Y sky130_fd_sc_hd__inv_2
XFILLER_114_421 VGND VGND VPWR VPWR sky130_fd_sc_hd__fill_2
XFILLER_99_154 VGND VGND VPWR VPWR sky130_fd_sc_hd__decap_3
XFILLER_87_305 VGND VGND VPWR VPWR sky130_fd_sc_hd__fill_1
X_5274_ _5274_/A0 _5079_/X _5274_/S VGND VGND VPWR VPWR _7193_/D sky130_fd_sc_hd__mux2_2
XFILLER_101_137 VGND VGND VPWR VPWR sky130_fd_sc_hd__decap_3
XFILLER_68_530 VGND VGND VPWR VPWR sky130_fd_sc_hd__fill_2
XFILLER_87_349 VGND VGND VPWR VPWR sky130_fd_sc_hd__decap_3
X_7013_ _7357_/CLK _7013_/D _6293_/Y VGND VGND VPWR VPWR _7013_/Q sky130_fd_sc_hd__dfrtp_2
X_4225_ _4371_/A _4371_/B _4224_/C VGND VGND VPWR VPWR _4627_/A sky130_fd_sc_hd__a21oi_2
XFILLER_110_660 VGND VGND VPWR VPWR sky130_fd_sc_hd__decap_3
XFILLER_83_500 VGND VGND VPWR VPWR sky130_fd_sc_hd__decap_3
X_4156_ _4157_/A _4205_/C VGND VGND VPWR VPWR _4158_/A sky130_fd_sc_hd__or2_2
XFILLER_110_693 VGND VGND VPWR VPWR sky130_fd_sc_hd__decap_3
XFILLER_28_416 VGND VGND VPWR VPWR sky130_fd_sc_hd__fill_1
XFILLER_95_393 VGND VGND VPWR VPWR sky130_fd_sc_hd__decap_3
XFILLER_43_408 VGND VGND VPWR VPWR sky130_fd_sc_hd__fill_1
XFILLER_55_246 VGND VGND VPWR VPWR sky130_fd_sc_hd__decap_3
XFILLER_71_706 VGND VGND VPWR VPWR sky130_fd_sc_hd__decap_3
X_4087_ _7078_/Q _4265_/B _4432_/B1 _4086_/X VGND VGND VPWR VPWR _4095_/A sky130_fd_sc_hd__o211ai_2
XFILLER_102_24 VGND VGND VPWR VPWR sky130_fd_sc_hd__decap_3
XFILLER_102_46 VGND VGND VPWR VPWR sky130_fd_sc_hd__fill_1
XFILLER_36_460 VGND VGND VPWR VPWR sky130_fd_sc_hd__decap_3
XFILLER_55_279 VGND VGND VPWR VPWR sky130_fd_sc_hd__fill_1
XFILLER_70_227 VGND VGND VPWR VPWR sky130_fd_sc_hd__fill_2
XFILLER_83_588 VGND VGND VPWR VPWR sky130_fd_sc_hd__decap_3
XTAP_TAPCELL_ROW_54_937 VGND VPWR sky130_fd_sc_hd__tapvpwrvgnd_1
XFILLER_23_110 VGND VGND VPWR VPWR sky130_fd_sc_hd__fill_2
XFILLER_24_622 VGND VGND VPWR VPWR sky130_fd_sc_hd__decap_3
XFILLER_24_666 VGND VGND VPWR VPWR sky130_fd_sc_hd__decap_3
XFILLER_51_463 VGND VGND VPWR VPWR sky130_fd_sc_hd__fill_1
XFILLER_11_316 VGND VGND VPWR VPWR sky130_fd_sc_hd__decap_3
XFILLER_23_187 VGND VGND VPWR VPWR sky130_fd_sc_hd__decap_3
XFILLER_24_699 VGND VGND VPWR VPWR sky130_fd_sc_hd__fill_1
X_4989_ _5032_/A _5032_/B VGND VGND VPWR VPWR _4989_/X sky130_fd_sc_hd__or2b_2
XTAP_TAPCELL_ROW_34_683 VGND VPWR sky130_fd_sc_hd__tapvpwrvgnd_1
X_6728_ clkload6/A _6728_/D VGND VGND VPWR VPWR _6728_/Q sky130_fd_sc_hd__dfxtp_2
X_6659_ _6662_/A VGND VGND VPWR VPWR _6659_/Y sky130_fd_sc_hd__inv_2
XFILLER_117_270 VGND VGND VPWR VPWR sky130_fd_sc_hd__decap_3
XFILLER_11_43 VGND VGND VPWR VPWR sky130_fd_sc_hd__fill_2
XFILLER_3_526 VGND VGND VPWR VPWR sky130_fd_sc_hd__decap_3
XFILLER_105_443 VGND VGND VPWR VPWR sky130_fd_sc_hd__decap_3
XFILLER_3_559 VGND VGND VPWR VPWR sky130_fd_sc_hd__fill_1
XFILLER_105_498 VGND VGND VPWR VPWR sky130_fd_sc_hd__decap_3
XFILLER_78_338 VGND VGND VPWR VPWR sky130_fd_sc_hd__decap_3
XFILLER_87_69 VGND VGND VPWR VPWR sky130_fd_sc_hd__decap_3
XTAP_TAPCELL_ROW_6_331 VGND VPWR sky130_fd_sc_hd__tapvpwrvgnd_1
XFILLER_47_703 VGND VGND VPWR VPWR sky130_fd_sc_hd__decap_3
XFILLER_93_308 VGND VGND VPWR VPWR sky130_fd_sc_hd__decap_3
XFILLER_101_671 VGND VGND VPWR VPWR sky130_fd_sc_hd__fill_1
XFILLER_101_682 VGND VGND VPWR VPWR sky130_fd_sc_hd__decap_3
XFILLER_74_522 VGND VGND VPWR VPWR sky130_fd_sc_hd__decap_3
XTAP_TAPCELL_ROW_109_1626 VGND VPWR sky130_fd_sc_hd__tapvpwrvgnd_1
XTAP_TAPCELL_ROW_109_1615 VGND VPWR sky130_fd_sc_hd__tapvpwrvgnd_1
XFILLER_19_449 VGND VGND VPWR VPWR sky130_fd_sc_hd__decap_3
XFILLER_74_555 VGND VGND VPWR VPWR sky130_fd_sc_hd__decap_3
XFILLER_15_611 VGND VGND VPWR VPWR sky130_fd_sc_hd__decap_3
XFILLER_27_471 VGND VGND VPWR VPWR sky130_fd_sc_hd__decap_3
XFILLER_61_216 VGND VGND VPWR VPWR sky130_fd_sc_hd__decap_3
XFILLER_15_644 VGND VGND VPWR VPWR sky130_fd_sc_hd__decap_3
XFILLER_54_290 VGND VGND VPWR VPWR sky130_fd_sc_hd__fill_2
XFILLER_15_688 VGND VGND VPWR VPWR sky130_fd_sc_hd__decap_3
XFILLER_42_441 VGND VGND VPWR VPWR sky130_fd_sc_hd__decap_3
XFILLER_42_463 VGND VGND VPWR VPWR sky130_fd_sc_hd__decap_3
XFILLER_14_165 VGND VGND VPWR VPWR sky130_fd_sc_hd__fill_2
XFILLER_30_625 VGND VGND VPWR VPWR sky130_fd_sc_hd__decap_3
XFILLER_30_669 VGND VGND VPWR VPWR sky130_fd_sc_hd__decap_3
XFILLER_52_83 VGND VGND VPWR VPWR sky130_fd_sc_hd__fill_1
XFILLER_10_371 VGND VGND VPWR VPWR sky130_fd_sc_hd__decap_3
XFILLER_6_342 VGND VGND VPWR VPWR sky130_fd_sc_hd__decap_3
XFILLER_42_6 VGND VGND VPWR VPWR sky130_fd_sc_hd__decap_3
XFILLER_69_305 VGND VGND VPWR VPWR sky130_fd_sc_hd__fill_2
XFILLER_96_102 VGND VGND VPWR VPWR sky130_fd_sc_hd__decap_3
XFILLER_97_614 VGND VGND VPWR VPWR sky130_fd_sc_hd__fill_2
XFILLER_2_581 VGND VGND VPWR VPWR sky130_fd_sc_hd__decap_3
XFILLER_2_592 VGND VGND VPWR VPWR sky130_fd_sc_hd__decap_3
XFILLER_69_349 VGND VGND VPWR VPWR sky130_fd_sc_hd__decap_3
XFILLER_96_113 VGND VGND VPWR VPWR sky130_fd_sc_hd__decap_3
XFILLER_97_647 VGND VGND VPWR VPWR sky130_fd_sc_hd__decap_3
XFILLER_77_91 VGND VGND VPWR VPWR sky130_fd_sc_hd__decap_3
XFILLER_96_168 VGND VGND VPWR VPWR sky130_fd_sc_hd__decap_3
XFILLER_65_500 VGND VGND VPWR VPWR sky130_fd_sc_hd__decap_3
XFILLER_65_511 VGND VGND VPWR VPWR sky130_fd_sc_hd__decap_3
XFILLER_77_393 VGND VGND VPWR VPWR sky130_fd_sc_hd__decap_3
XFILLER_37_257 VGND VGND VPWR VPWR sky130_fd_sc_hd__decap_3
XFILLER_53_706 VGND VGND VPWR VPWR sky130_fd_sc_hd__decap_3
XFILLER_37_279 VGND VGND VPWR VPWR sky130_fd_sc_hd__fill_1
XFILLER_52_205 VGND VGND VPWR VPWR sky130_fd_sc_hd__decap_3
XFILLER_92_385 VGND VGND VPWR VPWR sky130_fd_sc_hd__decap_3
XTAP_TAPCELL_ROW_84_1309 VGND VPWR sky130_fd_sc_hd__tapvpwrvgnd_1
XFILLER_52_227 VGND VGND VPWR VPWR sky130_fd_sc_hd__decap_3
XFILLER_93_90 VGND VGND VPWR VPWR sky130_fd_sc_hd__decap_3
X_4912_ _4912_/A _4912_/B VGND VGND VPWR VPWR _6997_/D sky130_fd_sc_hd__nor2_2
XFILLER_21_603 VGND VGND VPWR VPWR sky130_fd_sc_hd__decap_3
XFILLER_33_452 VGND VGND VPWR VPWR sky130_fd_sc_hd__decap_3
XFILLER_21_647 VGND VGND VPWR VPWR sky130_fd_sc_hd__decap_3
XFILLER_33_474 VGND VGND VPWR VPWR sky130_fd_sc_hd__decap_3
X_4843_ _4111_/B _4842_/X _4633_/A VGND VGND VPWR VPWR _4843_/Y sky130_fd_sc_hd__a21oi_2
X_4774_ _7004_/Q _4801_/A VGND VGND VPWR VPWR _4775_/B sky130_fd_sc_hd__nor2_2
XTAP_TAPCELL_ROW_31_642 VGND VPWR sky130_fd_sc_hd__tapvpwrvgnd_1
X_6513_ _6680_/A VGND VGND VPWR VPWR _6513_/Y sky130_fd_sc_hd__inv_2
X_3725_ _3735_/A _3741_/B _3733_/C VGND VGND VPWR VPWR _3725_/X sky130_fd_sc_hd__and3_2
XFILLER_119_557 VGND VGND VPWR VPWR sky130_fd_sc_hd__decap_3
XFILLER_119_579 VGND VGND VPWR VPWR sky130_fd_sc_hd__decap_3
Xclkbuf_leaf_9_clk clkbuf_leaf_9_clk/A VGND VGND VPWR VPWR _6942_/CLK sky130_fd_sc_hd__clkbuf_16
X_6444_ _6644_/A VGND VGND VPWR VPWR _6444_/Y sky130_fd_sc_hd__inv_2
X_3656_ _3991_/B _3661_/B VGND VGND VPWR VPWR _3656_/Y sky130_fd_sc_hd__nor2_2
XTAP_TAPCELL_ROW_95_1449 VGND VPWR sky130_fd_sc_hd__tapvpwrvgnd_1
X_6375_ _6571_/A VGND VGND VPWR VPWR _6375_/Y sky130_fd_sc_hd__inv_2
X_3587_ _3599_/A _3600_/A VGND VGND VPWR VPWR _4292_/B sky130_fd_sc_hd__or2_4
XFILLER_102_435 VGND VGND VPWR VPWR sky130_fd_sc_hd__fill_1
XFILLER_114_295 VGND VGND VPWR VPWR sky130_fd_sc_hd__decap_3
XFILLER_87_113 VGND VGND VPWR VPWR sky130_fd_sc_hd__decap_3
XFILLER_88_636 VGND VGND VPWR VPWR sky130_fd_sc_hd__decap_3
XFILLER_29_703 VGND VGND VPWR VPWR sky130_fd_sc_hd__decap_3
XFILLER_75_308 VGND VGND VPWR VPWR sky130_fd_sc_hd__fill_2
XFILLER_87_146 VGND VGND VPWR VPWR sky130_fd_sc_hd__fill_2
XFILLER_88_669 VGND VGND VPWR VPWR sky130_fd_sc_hd__decap_3
X_4208_ _4886_/A _4208_/B VGND VGND VPWR VPWR _4903_/A sky130_fd_sc_hd__nor2_2
XTAP_TAPCELL_ROW_3_301 VGND VPWR sky130_fd_sc_hd__tapvpwrvgnd_1
XFILLER_113_12 VGND VGND VPWR VPWR sky130_fd_sc_hd__decap_3
XFILLER_56_500 VGND VGND VPWR VPWR sky130_fd_sc_hd__decap_3
XFILLER_68_371 VGND VGND VPWR VPWR sky130_fd_sc_hd__fill_1
X_5188_ _5188_/A _5207_/B VGND VGND VPWR VPWR _7234_/D sky130_fd_sc_hd__and2_2
XFILLER_113_23 VGND VGND VPWR VPWR sky130_fd_sc_hd__decap_3
XFILLER_28_224 VGND VGND VPWR VPWR sky130_fd_sc_hd__decap_3
XFILLER_28_235 VGND VGND VPWR VPWR sky130_fd_sc_hd__decap_3
XFILLER_56_533 VGND VGND VPWR VPWR sky130_fd_sc_hd__decap_3
XFILLER_56_566 VGND VGND VPWR VPWR sky130_fd_sc_hd__fill_1
X_4139_ _4207_/A _4642_/B VGND VGND VPWR VPWR _4886_/A sky130_fd_sc_hd__nor2_2
XTAP_TAPCELL_ROW_39_742 VGND VPWR sky130_fd_sc_hd__tapvpwrvgnd_1
XFILLER_113_78 VGND VGND VPWR VPWR sky130_fd_sc_hd__decap_3
XFILLER_16_408 VGND VGND VPWR VPWR sky130_fd_sc_hd__decap_3
XFILLER_43_205 VGND VGND VPWR VPWR sky130_fd_sc_hd__decap_3
XFILLER_71_503 VGND VGND VPWR VPWR sky130_fd_sc_hd__fill_1
XFILLER_71_547 VGND VGND VPWR VPWR sky130_fd_sc_hd__fill_1
XFILLER_24_452 VGND VGND VPWR VPWR sky130_fd_sc_hd__fill_2
XTAP_TAPCELL_ROW_104_1556 VGND VPWR sky130_fd_sc_hd__tapvpwrvgnd_1
XFILLER_11_113 VGND VGND VPWR VPWR sky130_fd_sc_hd__decap_3
XFILLER_12_625 VGND VGND VPWR VPWR sky130_fd_sc_hd__decap_3
XFILLER_11_146 VGND VGND VPWR VPWR sky130_fd_sc_hd__decap_3
XFILLER_12_669 VGND VGND VPWR VPWR sky130_fd_sc_hd__decap_3
XFILLER_51_293 VGND VGND VPWR VPWR sky130_fd_sc_hd__decap_3
XFILLER_8_607 VGND VGND VPWR VPWR sky130_fd_sc_hd__decap_3
XFILLER_3_334 VGND VGND VPWR VPWR sky130_fd_sc_hd__fill_2
XFILLER_105_251 VGND VGND VPWR VPWR sky130_fd_sc_hd__decap_3
XTAP_TAPCELL_ROW_115_1696 VGND VPWR sky130_fd_sc_hd__tapvpwrvgnd_1
XFILLER_78_124 VGND VGND VPWR VPWR sky130_fd_sc_hd__decap_3
XFILLER_79_647 VGND VGND VPWR VPWR sky130_fd_sc_hd__decap_3
XFILLER_78_157 VGND VGND VPWR VPWR sky130_fd_sc_hd__decap_3
XFILLER_87_691 VGND VGND VPWR VPWR sky130_fd_sc_hd__decap_3
XFILLER_93_105 VGND VGND VPWR VPWR sky130_fd_sc_hd__decap_3
XFILLER_93_116 VGND VGND VPWR VPWR sky130_fd_sc_hd__decap_3
XFILLER_94_628 VGND VGND VPWR VPWR sky130_fd_sc_hd__decap_3
XFILLER_35_706 VGND VGND VPWR VPWR sky130_fd_sc_hd__decap_3
XFILLER_47_555 VGND VGND VPWR VPWR sky130_fd_sc_hd__decap_3
XFILLER_59_393 VGND VGND VPWR VPWR sky130_fd_sc_hd__decap_3
XFILLER_93_149 VGND VGND VPWR VPWR sky130_fd_sc_hd__fill_1
XFILLER_19_268 VGND VGND VPWR VPWR sky130_fd_sc_hd__decap_3
XFILLER_47_94 VGND VGND VPWR VPWR sky130_fd_sc_hd__fill_2
XFILLER_62_525 VGND VGND VPWR VPWR sky130_fd_sc_hd__fill_1
XFILLER_74_363 VGND VGND VPWR VPWR sky130_fd_sc_hd__fill_1
XFILLER_74_374 VGND VGND VPWR VPWR sky130_fd_sc_hd__decap_3
XFILLER_34_238 VGND VGND VPWR VPWR sky130_fd_sc_hd__decap_3
XTAP_TAPCELL_ROW_17_469 VGND VPWR sky130_fd_sc_hd__tapvpwrvgnd_1
XFILLER_30_400 VGND VGND VPWR VPWR sky130_fd_sc_hd__fill_1
XFILLER_63_93 VGND VGND VPWR VPWR sky130_fd_sc_hd__decap_3
XFILLER_70_580 VGND VGND VPWR VPWR sky130_fd_sc_hd__decap_3
Xclkbuf_3_4__f_clk clkbuf_0_clk/X VGND VGND VPWR VPWR clkbuf_leaf_9_clk/A sky130_fd_sc_hd__clkbuf_16
XFILLER_30_433 VGND VGND VPWR VPWR sky130_fd_sc_hd__fill_1
XFILLER_30_455 VGND VGND VPWR VPWR sky130_fd_sc_hd__fill_1
XFILLER_42_293 VGND VGND VPWR VPWR sky130_fd_sc_hd__decap_3
XFILLER_8_22 VGND VGND VPWR VPWR sky130_fd_sc_hd__decap_3
XFILLER_30_477 VGND VGND VPWR VPWR sky130_fd_sc_hd__decap_3
XFILLER_11_691 VGND VGND VPWR VPWR sky130_fd_sc_hd__decap_3
XFILLER_8_88 VGND VGND VPWR VPWR sky130_fd_sc_hd__decap_3
X_3510_ _3330_/Y _3383_/B _3442_/B _6979_/Q VGND VGND VPWR VPWR _3510_/X sky130_fd_sc_hd__a2bb2o_2
XFILLER_6_150 VGND VGND VPWR VPWR sky130_fd_sc_hd__fill_1
XFILLER_7_662 VGND VGND VPWR VPWR sky130_fd_sc_hd__decap_3
XFILLER_7_673 VGND VGND VPWR VPWR sky130_fd_sc_hd__decap_3
XFILLER_109_590 VGND VGND VPWR VPWR sky130_fd_sc_hd__decap_3
X_3441_ _7058_/Q _4305_/B _3590_/A _3440_/X VGND VGND VPWR VPWR _3544_/A sky130_fd_sc_hd__o211ai_2
XFILLER_97_400 VGND VGND VPWR VPWR sky130_fd_sc_hd__decap_3
XFILLER_69_113 VGND VGND VPWR VPWR sky130_fd_sc_hd__decap_3
XFILLER_97_422 VGND VGND VPWR VPWR sky130_fd_sc_hd__decap_3
X_5111_ _3610_/A _3603_/Y _4292_/C _3548_/X VGND VGND VPWR VPWR _5111_/X sky130_fd_sc_hd__a31o_2
XFILLER_69_146 VGND VGND VPWR VPWR sky130_fd_sc_hd__decap_3
XFILLER_85_617 VGND VGND VPWR VPWR sky130_fd_sc_hd__decap_3
XFILLER_97_455 VGND VGND VPWR VPWR sky130_fd_sc_hd__fill_1
Xhold1307 _7248_/Q VGND VGND VPWR VPWR _5157_/A0 sky130_fd_sc_hd__dlygate4sd3_1
XTAP_TAPCELL_ROW_90_1379 VGND VPWR sky130_fd_sc_hd__tapvpwrvgnd_1
XFILLER_111_265 VGND VGND VPWR VPWR sky130_fd_sc_hd__decap_3
XFILLER_111_287 VGND VGND VPWR VPWR sky130_fd_sc_hd__decap_3
XFILLER_84_127 VGND VGND VPWR VPWR sky130_fd_sc_hd__decap_3
Xhold1318 _7358_/Q VGND VGND VPWR VPWR _3964_/A0 sky130_fd_sc_hd__dlygate4sd3_1
XFILLER_38_533 VGND VGND VPWR VPWR sky130_fd_sc_hd__fill_2
XFILLER_65_330 VGND VGND VPWR VPWR sky130_fd_sc_hd__decap_3
XFILLER_93_650 VGND VGND VPWR VPWR sky130_fd_sc_hd__decap_3
XFILLER_38_577 VGND VGND VPWR VPWR sky130_fd_sc_hd__decap_3
XTAP_TAPCELL_ROW_36_712 VGND VPWR sky130_fd_sc_hd__tapvpwrvgnd_1
XFILLER_25_238 VGND VGND VPWR VPWR sky130_fd_sc_hd__decap_3
XFILLER_80_333 VGND VGND VPWR VPWR sky130_fd_sc_hd__fill_2
XFILLER_92_171 VGND VGND VPWR VPWR sky130_fd_sc_hd__decap_3
XFILLER_93_694 VGND VGND VPWR VPWR sky130_fd_sc_hd__decap_3
X_6993_ _7396_/CLK _6993_/D _6273_/Y VGND VGND VPWR VPWR _6993_/Q sky130_fd_sc_hd__dfrtp_2
XFILLER_18_290 VGND VGND VPWR VPWR sky130_fd_sc_hd__decap_3
XFILLER_41_709 VGND VGND VPWR VPWR sky130_fd_sc_hd__decap_3
XFILLER_33_260 VGND VGND VPWR VPWR sky130_fd_sc_hd__decap_3
XFILLER_21_455 VGND VGND VPWR VPWR sky130_fd_sc_hd__decap_3
XFILLER_33_293 VGND VGND VPWR VPWR sky130_fd_sc_hd__decap_3
X_4826_ _4826_/A _4826_/B VGND VGND VPWR VPWR _7001_/D sky130_fd_sc_hd__nor2_2
XFILLER_119_332 VGND VGND VPWR VPWR sky130_fd_sc_hd__decap_3
X_4757_ _4757_/A _4665_/X VGND VGND VPWR VPWR _4759_/A sky130_fd_sc_hd__or2b_2
XFILLER_111_9 VGND VGND VPWR VPWR sky130_fd_sc_hd__decap_3
XFILLER_119_365 VGND VGND VPWR VPWR sky130_fd_sc_hd__decap_3
XFILLER_119_387 VGND VGND VPWR VPWR sky130_fd_sc_hd__decap_3
X_4688_ _7001_/Q _7002_/Q _4687_/B _4690_/B VGND VGND VPWR VPWR _4688_/X sky130_fd_sc_hd__a31o_2
X_3708_ _6801_/Q _3759_/A2 _3760_/B1 _6711_/Q _3707_/X VGND VGND VPWR VPWR _3708_/X
+ sky130_fd_sc_hd__a221o_2
XFILLER_108_12 VGND VGND VPWR VPWR sky130_fd_sc_hd__decap_3
X_6427_ _6556_/A VGND VGND VPWR VPWR _6427_/Y sky130_fd_sc_hd__inv_2
X_3639_ _3636_/Y _3548_/X _3505_/X _5020_/A _3638_/X VGND VGND VPWR VPWR _3639_/X
+ sky130_fd_sc_hd__o221a_2
XFILLER_103_700 VGND VGND VPWR VPWR sky130_fd_sc_hd__decap_3
XFILLER_108_56 VGND VGND VPWR VPWR sky130_fd_sc_hd__decap_3
X_6358_ _6649_/A VGND VGND VPWR VPWR _6358_/Y sky130_fd_sc_hd__inv_2
XFILLER_0_315 VGND VGND VPWR VPWR sky130_fd_sc_hd__decap_3
XFILLER_0_337 VGND VGND VPWR VPWR sky130_fd_sc_hd__decap_3
XFILLER_102_210 VGND VGND VPWR VPWR sky130_fd_sc_hd__decap_3
XFILLER_115_593 VGND VGND VPWR VPWR sky130_fd_sc_hd__decap_3
XFILLER_88_433 VGND VGND VPWR VPWR sky130_fd_sc_hd__decap_3
XFILLER_76_606 VGND VGND VPWR VPWR sky130_fd_sc_hd__decap_3
XFILLER_88_466 VGND VGND VPWR VPWR sky130_fd_sc_hd__decap_3
XFILLER_88_477 VGND VGND VPWR VPWR sky130_fd_sc_hd__decap_3
X_6289_ _6649_/A VGND VGND VPWR VPWR _6289_/Y sky130_fd_sc_hd__inv_2
XFILLER_102_265 VGND VGND VPWR VPWR sky130_fd_sc_hd__decap_3
XFILLER_29_511 VGND VGND VPWR VPWR sky130_fd_sc_hd__decap_3
XFILLER_76_639 VGND VGND VPWR VPWR sky130_fd_sc_hd__decap_3
XFILLER_56_330 VGND VGND VPWR VPWR sky130_fd_sc_hd__decap_3
XFILLER_69_691 VGND VGND VPWR VPWR sky130_fd_sc_hd__decap_3
XFILLER_75_138 VGND VGND VPWR VPWR sky130_fd_sc_hd__decap_3
XFILLER_84_15 VGND VGND VPWR VPWR sky130_fd_sc_hd__fill_1
XFILLER_17_706 VGND VGND VPWR VPWR sky130_fd_sc_hd__decap_3
XFILLER_29_588 VGND VGND VPWR VPWR sky130_fd_sc_hd__decap_3
XFILLER_84_672 VGND VGND VPWR VPWR sky130_fd_sc_hd__decap_3
XFILLER_16_216 VGND VGND VPWR VPWR sky130_fd_sc_hd__decap_3
XFILLER_44_525 VGND VGND VPWR VPWR sky130_fd_sc_hd__decap_3
XFILLER_83_193 VGND VGND VPWR VPWR sky130_fd_sc_hd__decap_3
XFILLER_16_249 VGND VGND VPWR VPWR sky130_fd_sc_hd__decap_3
XFILLER_31_208 VGND VGND VPWR VPWR sky130_fd_sc_hd__decap_3
XFILLER_44_569 VGND VGND VPWR VPWR sky130_fd_sc_hd__fill_1
XFILLER_71_355 VGND VGND VPWR VPWR sky130_fd_sc_hd__decap_3
XFILLER_12_411 VGND VGND VPWR VPWR sky130_fd_sc_hd__fill_2
XFILLER_71_388 VGND VGND VPWR VPWR sky130_fd_sc_hd__fill_1
XFILLER_71_399 VGND VGND VPWR VPWR sky130_fd_sc_hd__decap_3
XTAP_TAPCELL_ROW_65_1072 VGND VPWR sky130_fd_sc_hd__tapvpwrvgnd_1
XTAP_TAPCELL_ROW_14_428 VGND VPWR sky130_fd_sc_hd__tapvpwrvgnd_1
XTAP_TAPCELL_ROW_14_439 VGND VPWR sky130_fd_sc_hd__tapvpwrvgnd_1
XTAP_TAPCELL_ROW_117_1725 VGND VPWR sky130_fd_sc_hd__tapvpwrvgnd_1
XFILLER_4_632 VGND VGND VPWR VPWR sky130_fd_sc_hd__decap_3
XFILLER_99_709 VGND VGND VPWR VPWR sky130_fd_sc_hd__decap_3
XFILLER_4_654 VGND VGND VPWR VPWR sky130_fd_sc_hd__decap_3
XFILLER_98_219 VGND VGND VPWR VPWR sky130_fd_sc_hd__decap_3
XFILLER_4_687 VGND VGND VPWR VPWR sky130_fd_sc_hd__decap_3
XFILLER_67_606 VGND VGND VPWR VPWR sky130_fd_sc_hd__decap_3
XFILLER_67_617 VGND VGND VPWR VPWR sky130_fd_sc_hd__decap_3
XFILLER_79_455 VGND VGND VPWR VPWR sky130_fd_sc_hd__decap_3
XFILLER_79_488 VGND VGND VPWR VPWR sky130_fd_sc_hd__decap_3
XFILLER_94_414 VGND VGND VPWR VPWR sky130_fd_sc_hd__decap_3
XFILLER_66_138 VGND VGND VPWR VPWR sky130_fd_sc_hd__fill_2
XFILLER_35_503 VGND VGND VPWR VPWR sky130_fd_sc_hd__fill_1
XFILLER_75_650 VGND VGND VPWR VPWR sky130_fd_sc_hd__decap_3
XFILLER_81_119 VGND VGND VPWR VPWR sky130_fd_sc_hd__decap_3
XFILLER_47_396 VGND VGND VPWR VPWR sky130_fd_sc_hd__decap_3
XFILLER_74_171 VGND VGND VPWR VPWR sky130_fd_sc_hd__decap_3
XFILLER_75_694 VGND VGND VPWR VPWR sky130_fd_sc_hd__decap_3
XFILLER_90_631 VGND VGND VPWR VPWR sky130_fd_sc_hd__decap_3
XFILLER_23_709 VGND VGND VPWR VPWR sky130_fd_sc_hd__decap_3
XFILLER_90_675 VGND VGND VPWR VPWR sky130_fd_sc_hd__decap_3
XFILLER_15_293 VGND VGND VPWR VPWR sky130_fd_sc_hd__decap_3
X_5660_ _5660_/A _5660_/B _5660_/C _5660_/D VGND VGND VPWR VPWR _5661_/D sky130_fd_sc_hd__and4_2
XFILLER_30_241 VGND VGND VPWR VPWR sky130_fd_sc_hd__decap_3
XFILLER_88_3 VGND VGND VPWR VPWR sky130_fd_sc_hd__decap_3
XFILLER_90_91 VGND VGND VPWR VPWR sky130_fd_sc_hd__decap_3
X_4611_ _4611_/A VGND VGND VPWR VPWR _4611_/Y sky130_fd_sc_hd__inv_2
X_5591_ _5591_/A _5595_/B VGND VGND VPWR VPWR _7032_/D sky130_fd_sc_hd__or2_2
XTAP_TAPCELL_ROW_41_770 VGND VPWR sky130_fd_sc_hd__tapvpwrvgnd_1
X_7330_ _7333_/CLK _7330_/D _6610_/Y VGND VGND VPWR VPWR _7330_/Q sky130_fd_sc_hd__dfrtp_2
X_4542_ _4542_/A _4563_/B VGND VGND VPWR VPWR _7309_/D sky130_fd_sc_hd__and2_2
X_7261_ _7358_/CLK _7261_/D _6541_/Y VGND VGND VPWR VPWR _7261_/Q sky130_fd_sc_hd__dfrtp_2
XTAP_TAPCELL_ROW_92_1408 VGND VPWR sky130_fd_sc_hd__tapvpwrvgnd_1
XFILLER_89_208 VGND VGND VPWR VPWR sky130_fd_sc_hd__decap_3
X_3424_ _3398_/Y _3419_/Y _3424_/S VGND VGND VPWR VPWR _3590_/C sky130_fd_sc_hd__mux2_4
X_7192_ _7387_/CLK _7192_/D _6472_/Y VGND VGND VPWR VPWR _7192_/Q sky130_fd_sc_hd__dfrtp_2
XPHY_EDGE_ROW_115_Right_115 VGND VGND VPWR VPWR sky130_fd_sc_hd__decap_3
XFILLER_112_530 VGND VGND VPWR VPWR sky130_fd_sc_hd__fill_2
X_3355_ _3371_/A _5668_/A _3519_/B VGND VGND VPWR VPWR _3355_/Y sky130_fd_sc_hd__o21ai_2
XFILLER_112_574 VGND VGND VPWR VPWR sky130_fd_sc_hd__decap_3
XFILLER_57_105 VGND VGND VPWR VPWR sky130_fd_sc_hd__decap_3
XFILLER_58_628 VGND VGND VPWR VPWR sky130_fd_sc_hd__decap_3
XFILLER_85_414 VGND VGND VPWR VPWR sky130_fd_sc_hd__decap_3
Xhold1104 _7201_/Q VGND VGND VPWR VPWR _5258_/A0 sky130_fd_sc_hd__dlygate4sd3_1
Xhold1115 _7278_/Q VGND VGND VPWR VPWR _4718_/A0 sky130_fd_sc_hd__dlygate4sd3_1
XFILLER_57_149 VGND VGND VPWR VPWR sky130_fd_sc_hd__decap_3
XFILLER_85_458 VGND VGND VPWR VPWR sky130_fd_sc_hd__decap_3
XFILLER_97_296 VGND VGND VPWR VPWR sky130_fd_sc_hd__decap_3
Xhold1126 _7040_/Q VGND VGND VPWR VPWR _5577_/A0 sky130_fd_sc_hd__dlygate4sd3_1
Xhold1137 _7398_/Q VGND VGND VPWR VPWR _3750_/A1 sky130_fd_sc_hd__dlygate4sd3_1
Xhold1148 _7183_/Q VGND VGND VPWR VPWR _5292_/A0 sky130_fd_sc_hd__dlygate4sd3_1
X_5025_ _6989_/Q _5044_/A _6990_/Q VGND VGND VPWR VPWR _5026_/B sky130_fd_sc_hd__a21oi_2
XFILLER_66_672 VGND VGND VPWR VPWR sky130_fd_sc_hd__decap_3
Xhold1159 _7385_/Q VGND VGND VPWR VPWR _3864_/A0 sky130_fd_sc_hd__dlygate4sd3_1
XTAP_TAPCELL_ROW_49_870 VGND VPWR sky130_fd_sc_hd__tapvpwrvgnd_1
XFILLER_38_385 VGND VGND VPWR VPWR sky130_fd_sc_hd__decap_3
XFILLER_65_182 VGND VGND VPWR VPWR sky130_fd_sc_hd__decap_3
XFILLER_81_620 VGND VGND VPWR VPWR sky130_fd_sc_hd__decap_3
XFILLER_80_130 VGND VGND VPWR VPWR sky130_fd_sc_hd__decap_3
XFILLER_80_141 VGND VGND VPWR VPWR sky130_fd_sc_hd__decap_3
XFILLER_81_653 VGND VGND VPWR VPWR sky130_fd_sc_hd__decap_3
X_6976_ clkload3/A _6976_/D VGND VGND VPWR VPWR _6976_/Q sky130_fd_sc_hd__dfxtp_2
XFILLER_110_35 VGND VGND VPWR VPWR sky130_fd_sc_hd__decap_3
XFILLER_53_399 VGND VGND VPWR VPWR sky130_fd_sc_hd__decap_3
XFILLER_81_697 VGND VGND VPWR VPWR sky130_fd_sc_hd__decap_3
XTAP_TAPCELL_ROW_101_1515 VGND VPWR sky130_fd_sc_hd__tapvpwrvgnd_1
XFILLER_110_68 VGND VGND VPWR VPWR sky130_fd_sc_hd__decap_3
XTAP_TAPCELL_ROW_101_1526 VGND VPWR sky130_fd_sc_hd__tapvpwrvgnd_1
XFILLER_21_263 VGND VGND VPWR VPWR sky130_fd_sc_hd__decap_3
X_4809_ _7002_/Q _4826_/A VGND VGND VPWR VPWR _7002_/D sky130_fd_sc_hd__xor2_2
XPHY_EDGE_ROW_17_Right_17 VGND VGND VPWR VPWR sky130_fd_sc_hd__decap_3
XFILLER_107_302 VGND VGND VPWR VPWR sky130_fd_sc_hd__decap_3
XFILLER_107_346 VGND VGND VPWR VPWR sky130_fd_sc_hd__decap_3
XFILLER_119_195 VGND VGND VPWR VPWR sky130_fd_sc_hd__fill_1
XFILLER_119_66 VGND VGND VPWR VPWR sky130_fd_sc_hd__decap_3
XFILLER_79_15 VGND VGND VPWR VPWR sky130_fd_sc_hd__fill_1
XFILLER_119_99 VGND VGND VPWR VPWR sky130_fd_sc_hd__decap_3
XFILLER_1_635 VGND VGND VPWR VPWR sky130_fd_sc_hd__decap_3
Xhold960 _7085_/Q VGND VGND VPWR VPWR _7085_/D sky130_fd_sc_hd__dlygate4sd3_1
Xhold971 _7082_/Q VGND VGND VPWR VPWR _7082_/D sky130_fd_sc_hd__dlygate4sd3_1
Xhold982 _7070_/Q VGND VGND VPWR VPWR _7070_/D sky130_fd_sc_hd__dlygate4sd3_1
XFILLER_1_668 VGND VGND VPWR VPWR sky130_fd_sc_hd__decap_3
XFILLER_88_230 VGND VGND VPWR VPWR sky130_fd_sc_hd__decap_3
Xhold993 _7099_/Q VGND VGND VPWR VPWR _7099_/D sky130_fd_sc_hd__dlygate4sd3_1
XTAP_TAPCELL_ROW_112_1655 VGND VPWR sky130_fd_sc_hd__tapvpwrvgnd_1
XFILLER_1_679 VGND VGND VPWR VPWR sky130_fd_sc_hd__decap_3
XFILLER_49_617 VGND VGND VPWR VPWR sky130_fd_sc_hd__decap_3
XFILLER_88_274 VGND VGND VPWR VPWR sky130_fd_sc_hd__decap_3
XPHY_EDGE_ROW_26_Right_26 VGND VGND VPWR VPWR sky130_fd_sc_hd__decap_3
XFILLER_28_41 VGND VGND VPWR VPWR sky130_fd_sc_hd__decap_3
XFILLER_48_127 VGND VGND VPWR VPWR sky130_fd_sc_hd__decap_3
XFILLER_95_69 VGND VGND VPWR VPWR sky130_fd_sc_hd__decap_3
XFILLER_29_352 VGND VGND VPWR VPWR sky130_fd_sc_hd__decap_3
XFILLER_57_650 VGND VGND VPWR VPWR sky130_fd_sc_hd__decap_3
XFILLER_63_108 VGND VGND VPWR VPWR sky130_fd_sc_hd__decap_3
XFILLER_63_119 VGND VGND VPWR VPWR sky130_fd_sc_hd__decap_3
XFILLER_29_385 VGND VGND VPWR VPWR sky130_fd_sc_hd__decap_3
XFILLER_29_396 VGND VGND VPWR VPWR sky130_fd_sc_hd__decap_3
XFILLER_56_171 VGND VGND VPWR VPWR sky130_fd_sc_hd__fill_2
XFILLER_57_694 VGND VGND VPWR VPWR sky130_fd_sc_hd__decap_3
XFILLER_72_631 VGND VGND VPWR VPWR sky130_fd_sc_hd__decap_3
XTAP_TAPCELL_ROW_67_1101 VGND VPWR sky130_fd_sc_hd__tapvpwrvgnd_1
XFILLER_17_569 VGND VGND VPWR VPWR sky130_fd_sc_hd__decap_3
XFILLER_44_355 VGND VGND VPWR VPWR sky130_fd_sc_hd__decap_3
XFILLER_56_193 VGND VGND VPWR VPWR sky130_fd_sc_hd__decap_3
XFILLER_71_130 VGND VGND VPWR VPWR sky130_fd_sc_hd__decap_3
XFILLER_72_675 VGND VGND VPWR VPWR sky130_fd_sc_hd__decap_3
XFILLER_32_528 VGND VGND VPWR VPWR sky130_fd_sc_hd__fill_1
XFILLER_32_539 VGND VGND VPWR VPWR sky130_fd_sc_hd__decap_3
XFILLER_44_377 VGND VGND VPWR VPWR sky130_fd_sc_hd__decap_3
XFILLER_71_196 VGND VGND VPWR VPWR sky130_fd_sc_hd__decap_3
XTAP_TAPCELL_ROW_27_597 VGND VPWR sky130_fd_sc_hd__tapvpwrvgnd_1
XFILLER_12_263 VGND VGND VPWR VPWR sky130_fd_sc_hd__decap_3
XPHY_EDGE_ROW_35_Right_35 VGND VGND VPWR VPWR sky130_fd_sc_hd__decap_3
XFILLER_12_296 VGND VGND VPWR VPWR sky130_fd_sc_hd__decap_3
XFILLER_8_223 VGND VGND VPWR VPWR sky130_fd_sc_hd__fill_1
XFILLER_8_256 VGND VGND VPWR VPWR sky130_fd_sc_hd__fill_1
XFILLER_8_267 VGND VGND VPWR VPWR sky130_fd_sc_hd__decap_3
XFILLER_60_94 VGND VGND VPWR VPWR sky130_fd_sc_hd__decap_3
XTAP_TAPCELL_ROW_78_1230 VGND VPWR sky130_fd_sc_hd__tapvpwrvgnd_1
XFILLER_4_440 VGND VGND VPWR VPWR sky130_fd_sc_hd__fill_1
XFILLER_5_34 VGND VGND VPWR VPWR sky130_fd_sc_hd__fill_1
XFILLER_99_517 VGND VGND VPWR VPWR sky130_fd_sc_hd__decap_3
XFILLER_4_495 VGND VGND VPWR VPWR sky130_fd_sc_hd__decap_3
XPHY_EDGE_ROW_44_Right_44 VGND VGND VPWR VPWR sky130_fd_sc_hd__decap_3
XFILLER_67_414 VGND VGND VPWR VPWR sky130_fd_sc_hd__decap_3
XFILLER_79_252 VGND VGND VPWR VPWR sky130_fd_sc_hd__decap_3
XFILLER_79_274 VGND VGND VPWR VPWR sky130_fd_sc_hd__decap_3
XFILLER_94_200 VGND VGND VPWR VPWR sky130_fd_sc_hd__decap_3
XFILLER_95_712 VGND VGND VPWR VPWR sky130_fd_sc_hd__fill_2
XFILLER_94_244 VGND VGND VPWR VPWR sky130_fd_sc_hd__decap_3
XFILLER_48_672 VGND VGND VPWR VPWR sky130_fd_sc_hd__decap_3
XFILLER_54_108 VGND VGND VPWR VPWR sky130_fd_sc_hd__decap_3
XFILLER_55_609 VGND VGND VPWR VPWR sky130_fd_sc_hd__decap_3
XFILLER_82_406 VGND VGND VPWR VPWR sky130_fd_sc_hd__fill_2
XFILLER_82_417 VGND VGND VPWR VPWR sky130_fd_sc_hd__decap_3
XFILLER_94_266 VGND VGND VPWR VPWR sky130_fd_sc_hd__decap_3
XPHY_EDGE_ROW_19_Left_139 VGND VGND VPWR VPWR sky130_fd_sc_hd__decap_3
XFILLER_63_620 VGND VGND VPWR VPWR sky130_fd_sc_hd__decap_3
XFILLER_94_299 VGND VGND VPWR VPWR sky130_fd_sc_hd__decap_3
XTAP_TAPCELL_ROW_89_1370 VGND VPWR sky130_fd_sc_hd__tapvpwrvgnd_1
XFILLER_47_193 VGND VGND VPWR VPWR sky130_fd_sc_hd__decap_3
XFILLER_62_141 VGND VGND VPWR VPWR sky130_fd_sc_hd__decap_3
XFILLER_63_653 VGND VGND VPWR VPWR sky130_fd_sc_hd__decap_3
X_6830_ _6983_/CLK _6830_/D VGND VGND VPWR VPWR _6830_/Q sky130_fd_sc_hd__dfxtp_2
XFILLER_23_517 VGND VGND VPWR VPWR sky130_fd_sc_hd__decap_3
XFILLER_23_539 VGND VGND VPWR VPWR sky130_fd_sc_hd__fill_1
XFILLER_63_697 VGND VGND VPWR VPWR sky130_fd_sc_hd__decap_3
XFILLER_90_461 VGND VGND VPWR VPWR sky130_fd_sc_hd__decap_3
XFILLER_90_483 VGND VGND VPWR VPWR sky130_fd_sc_hd__decap_3
X_6761_ clkload4/A _6761_/D VGND VGND VPWR VPWR _6761_/Q sky130_fd_sc_hd__dfxtp_2
X_5712_ _7362_/Q _5712_/A1 _5721_/S VGND VGND VPWR VPWR _6706_/D sky130_fd_sc_hd__mux2_2
X_3973_ _7354_/Q _4515_/A0 _3975_/S VGND VGND VPWR VPWR _7354_/D sky130_fd_sc_hd__mux2_2
XPHY_EDGE_ROW_53_Right_53 VGND VGND VPWR VPWR sky130_fd_sc_hd__decap_3
X_6692_ _7344_/CLK _6692_/D VGND VGND VPWR VPWR _6692_/Q sky130_fd_sc_hd__dfxtp_2
XFILLER_31_583 VGND VGND VPWR VPWR sky130_fd_sc_hd__decap_3
X_5643_ _5643_/A VGND VGND VPWR VPWR _5643_/X sky130_fd_sc_hd__buf_1
XFILLER_117_600 VGND VGND VPWR VPWR sky130_fd_sc_hd__decap_3
X_5574_ _5574_/A1 _4960_/A _4983_/X VGND VGND VPWR VPWR _7043_/D sky130_fd_sc_hd__a21o_2
XPHY_EDGE_ROW_28_Left_148 VGND VGND VPWR VPWR sky130_fd_sc_hd__decap_3
XFILLER_117_644 VGND VGND VPWR VPWR sky130_fd_sc_hd__decap_3
X_7313_ _7313_/CLK _7313_/D _6593_/Y VGND VGND VPWR VPWR _7313_/Q sky130_fd_sc_hd__dfrtp_2
XFILLER_104_305 VGND VGND VPWR VPWR sky130_fd_sc_hd__decap_3
XFILLER_117_688 VGND VGND VPWR VPWR sky130_fd_sc_hd__decap_3
XFILLER_104_327 VGND VGND VPWR VPWR sky130_fd_sc_hd__decap_3
XFILLER_116_165 VGND VGND VPWR VPWR sky130_fd_sc_hd__decap_3
X_7244_ _7372_/CLK _7244_/D _6524_/Y VGND VGND VPWR VPWR _7244_/Q sky130_fd_sc_hd__dfrtp_2
X_4456_ _4456_/A _4054_/A VGND VGND VPWR VPWR _4456_/X sky130_fd_sc_hd__or2b_2
XPHY_EDGE_ROW_62_Right_62 VGND VGND VPWR VPWR sky130_fd_sc_hd__decap_3
X_7175_ _7406_/CLK _7175_/D _6455_/Y VGND VGND VPWR VPWR _7175_/Q sky130_fd_sc_hd__dfrtp_2
X_4387_ _7241_/Q _4430_/A2 _4459_/C1 _7177_/Q _4386_/X VGND VGND VPWR VPWR _4387_/X
+ sky130_fd_sc_hd__a221o_2
X_3407_ _3421_/B _3421_/C _3417_/C VGND VGND VPWR VPWR _3407_/X sky130_fd_sc_hd__and3_2
XFILLER_100_500 VGND VGND VPWR VPWR sky130_fd_sc_hd__decap_3
XFILLER_112_371 VGND VGND VPWR VPWR sky130_fd_sc_hd__decap_3
XFILLER_86_701 VGND VGND VPWR VPWR sky130_fd_sc_hd__decap_3
XFILLER_98_572 VGND VGND VPWR VPWR sky130_fd_sc_hd__decap_3
XPHY_EDGE_ROW_0_Left_120 VGND VGND VPWR VPWR sky130_fd_sc_hd__decap_3
XFILLER_100_533 VGND VGND VPWR VPWR sky130_fd_sc_hd__decap_3
XFILLER_105_57 VGND VGND VPWR VPWR sky130_fd_sc_hd__decap_3
XFILLER_58_436 VGND VGND VPWR VPWR sky130_fd_sc_hd__decap_3
XFILLER_85_222 VGND VGND VPWR VPWR sky130_fd_sc_hd__fill_2
XPHY_EDGE_ROW_37_Left_157 VGND VGND VPWR VPWR sky130_fd_sc_hd__decap_3
XFILLER_39_650 VGND VGND VPWR VPWR sky130_fd_sc_hd__decap_3
XFILLER_58_469 VGND VGND VPWR VPWR sky130_fd_sc_hd__decap_3
XFILLER_85_255 VGND VGND VPWR VPWR sky130_fd_sc_hd__fill_2
XFILLER_38_182 VGND VGND VPWR VPWR sky130_fd_sc_hd__decap_3
XFILLER_39_694 VGND VGND VPWR VPWR sky130_fd_sc_hd__decap_3
XFILLER_66_480 VGND VGND VPWR VPWR sky130_fd_sc_hd__fill_2
XFILLER_85_299 VGND VGND VPWR VPWR sky130_fd_sc_hd__decap_3
X_5008_ _4680_/A _5015_/B _4960_/A VGND VGND VPWR VPWR _5009_/B sky130_fd_sc_hd__a21o_2
XFILLER_26_344 VGND VGND VPWR VPWR sky130_fd_sc_hd__decap_3
XFILLER_54_642 VGND VGND VPWR VPWR sky130_fd_sc_hd__fill_2
XFILLER_54_675 VGND VGND VPWR VPWR sky130_fd_sc_hd__decap_3
XPHY_EDGE_ROW_71_Right_71 VGND VGND VPWR VPWR sky130_fd_sc_hd__decap_3
XFILLER_53_185 VGND VGND VPWR VPWR sky130_fd_sc_hd__decap_3
XFILLER_81_49 VGND VGND VPWR VPWR sky130_fd_sc_hd__decap_3
X_6959_ clkload9/A _6959_/D VGND VGND VPWR VPWR _6959_/Q sky130_fd_sc_hd__dfxtp_2
XFILLER_10_701 VGND VGND VPWR VPWR sky130_fd_sc_hd__decap_3
XFILLER_14_43 VGND VGND VPWR VPWR sky130_fd_sc_hd__fill_2
XTAP_TAPCELL_ROW_62_1031 VGND VPWR sky130_fd_sc_hd__tapvpwrvgnd_1
XTAP_TAPCELL_ROW_24_556 VGND VPWR sky130_fd_sc_hd__tapvpwrvgnd_1
XPHY_EDGE_ROW_46_Left_166 VGND VGND VPWR VPWR sky130_fd_sc_hd__decap_3
XFILLER_108_622 VGND VGND VPWR VPWR sky130_fd_sc_hd__decap_3
XFILLER_107_143 VGND VGND VPWR VPWR sky130_fd_sc_hd__fill_1
XFILLER_108_666 VGND VGND VPWR VPWR sky130_fd_sc_hd__decap_3
XFILLER_5_248 VGND VGND VPWR VPWR sky130_fd_sc_hd__decap_3
XPHY_EDGE_ROW_80_Right_80 VGND VGND VPWR VPWR sky130_fd_sc_hd__decap_3
XFILLER_108_699 VGND VGND VPWR VPWR sky130_fd_sc_hd__fill_1
XFILLER_1_432 VGND VGND VPWR VPWR sky130_fd_sc_hd__decap_3
Xhold790 _6969_/Q VGND VGND VPWR VPWR _6969_/D sky130_fd_sc_hd__dlygate4sd3_1
XFILLER_1_454 VGND VGND VPWR VPWR sky130_fd_sc_hd__decap_3
XFILLER_77_712 VGND VGND VPWR VPWR sky130_fd_sc_hd__fill_2
XFILLER_89_561 VGND VGND VPWR VPWR sky130_fd_sc_hd__decap_3
XTAP_TAPCELL_ROW_73_1171 VGND VPWR sky130_fd_sc_hd__tapvpwrvgnd_1
XPHY_EDGE_ROW_55_Left_175 VGND VGND VPWR VPWR sky130_fd_sc_hd__decap_3
XFILLER_103_371 VGND VGND VPWR VPWR sky130_fd_sc_hd__decap_3
XFILLER_103_393 VGND VGND VPWR VPWR sky130_fd_sc_hd__decap_3
XFILLER_1_487 VGND VGND VPWR VPWR sky130_fd_sc_hd__decap_3
XFILLER_49_436 VGND VGND VPWR VPWR sky130_fd_sc_hd__decap_3
XFILLER_64_417 VGND VGND VPWR VPWR sky130_fd_sc_hd__decap_3
XFILLER_76_277 VGND VGND VPWR VPWR sky130_fd_sc_hd__decap_3
XFILLER_92_704 VGND VGND VPWR VPWR sky130_fd_sc_hd__decap_3
XFILLER_45_620 VGND VGND VPWR VPWR sky130_fd_sc_hd__decap_3
XFILLER_91_225 VGND VGND VPWR VPWR sky130_fd_sc_hd__decap_3
XFILLER_17_333 VGND VGND VPWR VPWR sky130_fd_sc_hd__decap_3
XFILLER_29_193 VGND VGND VPWR VPWR sky130_fd_sc_hd__decap_3
XFILLER_45_653 VGND VGND VPWR VPWR sky130_fd_sc_hd__decap_3
XFILLER_45_697 VGND VGND VPWR VPWR sky130_fd_sc_hd__decap_3
XFILLER_17_399 VGND VGND VPWR VPWR sky130_fd_sc_hd__decap_3
XFILLER_60_634 VGND VGND VPWR VPWR sky130_fd_sc_hd__decap_3
XFILLER_60_645 VGND VGND VPWR VPWR sky130_fd_sc_hd__decap_3
XPHY_EDGE_ROW_64_Left_184 VGND VGND VPWR VPWR sky130_fd_sc_hd__decap_3
XFILLER_13_550 VGND VGND VPWR VPWR sky130_fd_sc_hd__fill_2
XFILLER_13_561 VGND VGND VPWR VPWR sky130_fd_sc_hd__decap_3
XFILLER_60_678 VGND VGND VPWR VPWR sky130_fd_sc_hd__decap_3
XFILLER_13_594 VGND VGND VPWR VPWR sky130_fd_sc_hd__decap_3
XFILLER_71_60 VGND VGND VPWR VPWR sky130_fd_sc_hd__fill_1
XFILLER_71_71 VGND VGND VPWR VPWR sky130_fd_sc_hd__decap_3
XFILLER_9_521 VGND VGND VPWR VPWR sky130_fd_sc_hd__decap_3
XFILLER_40_391 VGND VGND VPWR VPWR sky130_fd_sc_hd__decap_3
XFILLER_72_6 VGND VGND VPWR VPWR sky130_fd_sc_hd__decap_3
XFILLER_9_576 VGND VGND VPWR VPWR sky130_fd_sc_hd__decap_3
XFILLER_9_554 VGND VGND VPWR VPWR sky130_fd_sc_hd__decap_3
XFILLER_113_113 VGND VGND VPWR VPWR sky130_fd_sc_hd__decap_3
XFILLER_114_625 VGND VGND VPWR VPWR sky130_fd_sc_hd__decap_3
X_5290_ _5290_/A0 _5156_/X _5292_/S VGND VGND VPWR VPWR _7184_/D sky130_fd_sc_hd__mux2_2
X_4310_ _7352_/Q _4416_/A2 _4352_/B1 _7160_/Q VGND VGND VPWR VPWR _4311_/C sky130_fd_sc_hd__a22o_2
XFILLER_99_314 VGND VGND VPWR VPWR sky130_fd_sc_hd__fill_2
XFILLER_114_669 VGND VGND VPWR VPWR sky130_fd_sc_hd__decap_3
X_4241_ _5018_/B _4241_/B VGND VGND VPWR VPWR _5032_/A sky130_fd_sc_hd__or2_2
XPHY_EDGE_ROW_73_Left_193 VGND VGND VPWR VPWR sky130_fd_sc_hd__decap_3
XFILLER_101_319 VGND VGND VPWR VPWR sky130_fd_sc_hd__decap_3
XFILLER_68_701 VGND VGND VPWR VPWR sky130_fd_sc_hd__decap_3
XFILLER_67_222 VGND VGND VPWR VPWR sky130_fd_sc_hd__fill_2
XFILLER_95_520 VGND VGND VPWR VPWR sky130_fd_sc_hd__decap_3
X_4172_ _4938_/B _4379_/B VGND VGND VPWR VPWR _4936_/A sky130_fd_sc_hd__nor2_2
XFILLER_55_406 VGND VGND VPWR VPWR sky130_fd_sc_hd__decap_3
XFILLER_27_119 VGND VGND VPWR VPWR sky130_fd_sc_hd__fill_2
XFILLER_55_417 VGND VGND VPWR VPWR sky130_fd_sc_hd__decap_3
XFILLER_67_277 VGND VGND VPWR VPWR sky130_fd_sc_hd__decap_3
XFILLER_82_203 VGND VGND VPWR VPWR sky130_fd_sc_hd__decap_3
XFILLER_82_225 VGND VGND VPWR VPWR sky130_fd_sc_hd__decap_3
XFILLER_95_597 VGND VGND VPWR VPWR sky130_fd_sc_hd__fill_1
XFILLER_36_631 VGND VGND VPWR VPWR sky130_fd_sc_hd__decap_3
XFILLER_70_409 VGND VGND VPWR VPWR sky130_fd_sc_hd__decap_3
XFILLER_23_303 VGND VGND VPWR VPWR sky130_fd_sc_hd__decap_3
XFILLER_35_163 VGND VGND VPWR VPWR sky130_fd_sc_hd__decap_3
XFILLER_36_675 VGND VGND VPWR VPWR sky130_fd_sc_hd__decap_3
XFILLER_51_612 VGND VGND VPWR VPWR sky130_fd_sc_hd__decap_3
XFILLER_51_623 VGND VGND VPWR VPWR sky130_fd_sc_hd__decap_3
XFILLER_35_196 VGND VGND VPWR VPWR sky130_fd_sc_hd__decap_3
XFILLER_51_656 VGND VGND VPWR VPWR sky130_fd_sc_hd__decap_3
XFILLER_90_280 VGND VGND VPWR VPWR sky130_fd_sc_hd__decap_3
Xplace483 _3371_/Y VGND VGND VPWR VPWR _3994_/S sky130_fd_sc_hd__buf_2
Xplace472 _3371_/Y VGND VGND VPWR VPWR _3566_/A2 sky130_fd_sc_hd__buf_2
Xplace461 _4534_/S VGND VGND VPWR VPWR _4244_/B sky130_fd_sc_hd__buf_2
Xplace450 _7412_/A VGND VGND VPWR VPWR _5323_/S sky130_fd_sc_hd__buf_2
X_6813_ _6906_/CLK _6813_/D VGND VGND VPWR VPWR _6813_/Q sky130_fd_sc_hd__dfxtp_2
XFILLER_50_144 VGND VGND VPWR VPWR sky130_fd_sc_hd__decap_3
Xplace494 _5581_/S VGND VGND VPWR VPWR _4857_/A sky130_fd_sc_hd__buf_2
X_6744_ clkload7/A _6744_/D VGND VGND VPWR VPWR _6744_/Q sky130_fd_sc_hd__dfxtp_2
X_3956_ _7362_/Q _3956_/A1 _3964_/S VGND VGND VPWR VPWR _7362_/D sky130_fd_sc_hd__mux2_2
XFILLER_50_188 VGND VGND VPWR VPWR sky130_fd_sc_hd__decap_3
X_6675_ _6686_/A VGND VGND VPWR VPWR _6675_/Y sky130_fd_sc_hd__inv_2
XTAP_TAPCELL_ROW_21_526 VGND VPWR sky130_fd_sc_hd__tapvpwrvgnd_1
XTAP_TAPCELL_ROW_21_515 VGND VPWR sky130_fd_sc_hd__tapvpwrvgnd_1
X_5626_ _5626_/A _5634_/B VGND VGND VPWR VPWR _7015_/D sky130_fd_sc_hd__and2_2
X_3887_ _6694_/Q _3887_/A2 _3887_/B1 _6872_/Q _3886_/X VGND VGND VPWR VPWR _3887_/X
+ sky130_fd_sc_hd__a221o_2
XFILLER_105_603 VGND VGND VPWR VPWR sky130_fd_sc_hd__decap_3
XFILLER_104_113 VGND VGND VPWR VPWR sky130_fd_sc_hd__decap_3
XFILLER_105_647 VGND VGND VPWR VPWR sky130_fd_sc_hd__decap_3
XFILLER_116_12 VGND VGND VPWR VPWR sky130_fd_sc_hd__decap_3
X_7227_ _7355_/CLK _7227_/D _6507_/Y VGND VGND VPWR VPWR _7227_/Q sky130_fd_sc_hd__dfrtp_2
X_4439_ _4440_/A _4650_/B VGND VGND VPWR VPWR _4813_/B sky130_fd_sc_hd__or2_2
XFILLER_104_168 VGND VGND VPWR VPWR sky130_fd_sc_hd__decap_3
XFILLER_116_56 VGND VGND VPWR VPWR sky130_fd_sc_hd__decap_3
XFILLER_59_712 VGND VGND VPWR VPWR sky130_fd_sc_hd__fill_2
XFILLER_113_691 VGND VGND VPWR VPWR sky130_fd_sc_hd__decap_3
XFILLER_58_200 VGND VGND VPWR VPWR sky130_fd_sc_hd__decap_3
XFILLER_58_233 VGND VGND VPWR VPWR sky130_fd_sc_hd__decap_3
XFILLER_76_38 VGND VGND VPWR VPWR sky130_fd_sc_hd__fill_1
X_7158_ _7313_/CLK _7158_/D _6438_/Y VGND VGND VPWR VPWR _7158_/Q sky130_fd_sc_hd__dfrtp_2
XFILLER_100_330 VGND VGND VPWR VPWR sky130_fd_sc_hd__decap_3
XFILLER_74_704 VGND VGND VPWR VPWR sky130_fd_sc_hd__decap_3
X_7089_ _7313_/CLK _7089_/D _6369_/Y VGND VGND VPWR VPWR _7089_/Q sky130_fd_sc_hd__dfstp_2
XFILLER_100_396 VGND VGND VPWR VPWR sky130_fd_sc_hd__fill_1
XFILLER_27_620 VGND VGND VPWR VPWR sky130_fd_sc_hd__decap_3
XFILLER_73_225 VGND VGND VPWR VPWR sky130_fd_sc_hd__decap_3
XFILLER_86_586 VGND VGND VPWR VPWR sky130_fd_sc_hd__fill_2
XTAP_TAPCELL_ROW_29_626 VGND VPWR sky130_fd_sc_hd__tapvpwrvgnd_1
XTAP_TAPCELL_ROW_29_615 VGND VPWR sky130_fd_sc_hd__tapvpwrvgnd_1
XFILLER_27_653 VGND VGND VPWR VPWR sky130_fd_sc_hd__decap_3
XTAP_TAPCELL_ROW_57_968 VGND VPWR sky130_fd_sc_hd__tapvpwrvgnd_1
XFILLER_27_697 VGND VGND VPWR VPWR sky130_fd_sc_hd__decap_3
XFILLER_42_612 VGND VGND VPWR VPWR sky130_fd_sc_hd__decap_3
XTAP_TAPCELL_ROW_1_273 VGND VPWR sky130_fd_sc_hd__tapvpwrvgnd_1
XFILLER_42_645 VGND VGND VPWR VPWR sky130_fd_sc_hd__decap_3
XTAP_TAPCELL_ROW_107_1598 VGND VPWR sky130_fd_sc_hd__tapvpwrvgnd_1
XFILLER_14_358 VGND VGND VPWR VPWR sky130_fd_sc_hd__decap_3
XFILLER_41_144 VGND VGND VPWR VPWR sky130_fd_sc_hd__decap_3
XFILLER_42_678 VGND VGND VPWR VPWR sky130_fd_sc_hd__decap_3
XFILLER_10_575 VGND VGND VPWR VPWR sky130_fd_sc_hd__decap_3
XFILLER_6_557 VGND VGND VPWR VPWR sky130_fd_sc_hd__decap_3
XTAP_TAPCELL_ROW_75_1200 VGND VPWR sky130_fd_sc_hd__tapvpwrvgnd_1
XFILLER_108_463 VGND VGND VPWR VPWR sky130_fd_sc_hd__decap_3
XFILLER_108_496 VGND VGND VPWR VPWR sky130_fd_sc_hd__decap_3
XFILLER_111_606 VGND VGND VPWR VPWR sky130_fd_sc_hd__decap_3
XFILLER_111_617 VGND VGND VPWR VPWR sky130_fd_sc_hd__decap_3
XFILLER_96_306 VGND VGND VPWR VPWR sky130_fd_sc_hd__fill_2
XTAP_TAPCELL_ROW_9_373 VGND VPWR sky130_fd_sc_hd__tapvpwrvgnd_1
XFILLER_110_127 VGND VGND VPWR VPWR sky130_fd_sc_hd__decap_3
XFILLER_1_262 VGND VGND VPWR VPWR sky130_fd_sc_hd__decap_3
XFILLER_1_284 VGND VGND VPWR VPWR sky130_fd_sc_hd__decap_3
XFILLER_49_222 VGND VGND VPWR VPWR sky130_fd_sc_hd__fill_2
XFILLER_2_46 VGND VGND VPWR VPWR sky130_fd_sc_hd__fill_2
XFILLER_49_266 VGND VGND VPWR VPWR sky130_fd_sc_hd__decap_3
XFILLER_92_501 VGND VGND VPWR VPWR sky130_fd_sc_hd__decap_3
XFILLER_37_417 VGND VGND VPWR VPWR sky130_fd_sc_hd__decap_3
XFILLER_49_299 VGND VGND VPWR VPWR sky130_fd_sc_hd__fill_1
XFILLER_64_225 VGND VGND VPWR VPWR sky130_fd_sc_hd__decap_3
XFILLER_17_130 VGND VGND VPWR VPWR sky130_fd_sc_hd__fill_2
XFILLER_18_631 VGND VGND VPWR VPWR sky130_fd_sc_hd__decap_3
XFILLER_80_707 VGND VGND VPWR VPWR sky130_fd_sc_hd__decap_3
XFILLER_17_163 VGND VGND VPWR VPWR sky130_fd_sc_hd__decap_3
XFILLER_18_675 VGND VGND VPWR VPWR sky130_fd_sc_hd__decap_3
XFILLER_33_612 VGND VGND VPWR VPWR sky130_fd_sc_hd__decap_3
XFILLER_45_472 VGND VGND VPWR VPWR sky130_fd_sc_hd__decap_3
XFILLER_92_578 VGND VGND VPWR VPWR sky130_fd_sc_hd__decap_3
XFILLER_32_122 VGND VGND VPWR VPWR sky130_fd_sc_hd__decap_3
XFILLER_33_623 VGND VGND VPWR VPWR sky130_fd_sc_hd__decap_3
XFILLER_33_656 VGND VGND VPWR VPWR sky130_fd_sc_hd__decap_3
XFILLER_60_453 VGND VGND VPWR VPWR sky130_fd_sc_hd__decap_3
XFILLER_82_70 VGND VGND VPWR VPWR sky130_fd_sc_hd__decap_3
X_4790_ _4781_/X _4782_/Y _4787_/Y _4948_/A _4789_/X VGND VGND VPWR VPWR _5664_/A
+ sky130_fd_sc_hd__o221a_2
X_3810_ _6846_/Q _3906_/A2 _3889_/B1 _6831_/Q _3809_/X VGND VGND VPWR VPWR _3810_/X
+ sky130_fd_sc_hd__a221o_2
XFILLER_32_166 VGND VGND VPWR VPWR sky130_fd_sc_hd__decap_3
X_3741_ _3746_/A _3741_/B _3746_/C VGND VGND VPWR VPWR _3741_/X sky130_fd_sc_hd__and3_4
XFILLER_13_380 VGND VGND VPWR VPWR sky130_fd_sc_hd__decap_3
X_6460_ _6556_/A VGND VGND VPWR VPWR _6460_/Y sky130_fd_sc_hd__inv_2
X_3672_ _3746_/A _3746_/B _3733_/C VGND VGND VPWR VPWR _3672_/X sky130_fd_sc_hd__or3_2
X_6391_ _6651_/A VGND VGND VPWR VPWR _6391_/Y sky130_fd_sc_hd__inv_2
X_5411_ _5411_/A0 _5094_/X _5427_/S VGND VGND VPWR VPWR _7128_/D sky130_fd_sc_hd__mux2_2
X_5342_ _5342_/A0 _5094_/X _7412_/A VGND VGND VPWR VPWR _7160_/D sky130_fd_sc_hd__mux2_2
XPHY_EDGE_ROW_81_Left_201 VGND VGND VPWR VPWR sky130_fd_sc_hd__decap_3
XFILLER_99_122 VGND VGND VPWR VPWR sky130_fd_sc_hd__decap_3
XFILLER_102_628 VGND VGND VPWR VPWR sky130_fd_sc_hd__decap_3
XFILLER_114_455 VGND VGND VPWR VPWR sky130_fd_sc_hd__decap_3
XFILLER_114_477 VGND VGND VPWR VPWR sky130_fd_sc_hd__fill_1
X_7012_ _7322_/CLK _7012_/D _6292_/Y VGND VGND VPWR VPWR _7012_/Q sky130_fd_sc_hd__dfrtp_2
XFILLER_99_166 VGND VGND VPWR VPWR sky130_fd_sc_hd__fill_2
XFILLER_101_116 VGND VGND VPWR VPWR sky130_fd_sc_hd__fill_1
X_4224_ _4371_/A _4371_/B _4224_/C VGND VGND VPWR VPWR _4372_/A sky130_fd_sc_hd__and3_2
XFILLER_99_188 VGND VGND VPWR VPWR sky130_fd_sc_hd__decap_3
XFILLER_101_149 VGND VGND VPWR VPWR sky130_fd_sc_hd__decap_3
XFILLER_56_704 VGND VGND VPWR VPWR sky130_fd_sc_hd__decap_3
XFILLER_95_350 VGND VGND VPWR VPWR sky130_fd_sc_hd__decap_3
X_4155_ _4151_/X _4154_/X _4425_/A VGND VGND VPWR VPWR _4205_/C sky130_fd_sc_hd__o21ai_2
XFILLER_110_672 VGND VGND VPWR VPWR sky130_fd_sc_hd__decap_3
XFILLER_28_439 VGND VGND VPWR VPWR sky130_fd_sc_hd__decap_3
XFILLER_55_203 VGND VGND VPWR VPWR sky130_fd_sc_hd__decap_3
XFILLER_55_225 VGND VGND VPWR VPWR sky130_fd_sc_hd__decap_3
XFILLER_83_523 VGND VGND VPWR VPWR sky130_fd_sc_hd__decap_3
XFILLER_95_383 VGND VGND VPWR VPWR sky130_fd_sc_hd__decap_3
XFILLER_55_258 VGND VGND VPWR VPWR sky130_fd_sc_hd__decap_3
X_4086_ _7270_/Q _4437_/A2 _3947_/S _7334_/Q _4085_/X VGND VGND VPWR VPWR _4086_/X
+ sky130_fd_sc_hd__a221o_2
XPHY_EDGE_ROW_90_Left_210 VGND VGND VPWR VPWR sky130_fd_sc_hd__decap_3
XFILLER_24_601 VGND VGND VPWR VPWR sky130_fd_sc_hd__decap_3
XFILLER_36_472 VGND VGND VPWR VPWR sky130_fd_sc_hd__decap_3
XTAP_TAPCELL_ROW_54_938 VGND VPWR sky130_fd_sc_hd__tapvpwrvgnd_1
XTAP_TAPCELL_ROW_54_927 VGND VPWR sky130_fd_sc_hd__tapvpwrvgnd_1
XFILLER_102_58 VGND VGND VPWR VPWR sky130_fd_sc_hd__decap_3
XFILLER_24_634 VGND VGND VPWR VPWR sky130_fd_sc_hd__decap_3
XFILLER_24_645 VGND VGND VPWR VPWR sky130_fd_sc_hd__decap_3
XFILLER_70_239 VGND VGND VPWR VPWR sky130_fd_sc_hd__decap_3
XFILLER_24_678 VGND VGND VPWR VPWR sky130_fd_sc_hd__decap_3
XFILLER_23_166 VGND VGND VPWR VPWR sky130_fd_sc_hd__fill_2
X_4988_ _4988_/A _4988_/B VGND VGND VPWR VPWR _5004_/A sky130_fd_sc_hd__nor2_2
XTAP_TAPCELL_ROW_34_684 VGND VPWR sky130_fd_sc_hd__tapvpwrvgnd_1
X_6727_ _6983_/CLK _6727_/D VGND VGND VPWR VPWR _6727_/Q sky130_fd_sc_hd__dfxtp_2
X_3939_ _7370_/Q _4482_/A0 _3954_/S VGND VGND VPWR VPWR _7370_/D sky130_fd_sc_hd__mux2_2
X_6658_ _6664_/A VGND VGND VPWR VPWR _6658_/Y sky130_fd_sc_hd__inv_2
XFILLER_109_249 VGND VGND VPWR VPWR sky130_fd_sc_hd__decap_3
X_5609_ _5609_/A _5633_/B VGND VGND VPWR VPWR _7023_/D sky130_fd_sc_hd__or2_2
XFILLER_3_505 VGND VGND VPWR VPWR sky130_fd_sc_hd__decap_3
X_6589_ _6650_/A VGND VGND VPWR VPWR _6589_/Y sky130_fd_sc_hd__inv_2
XFILLER_11_99 VGND VGND VPWR VPWR sky130_fd_sc_hd__fill_1
XFILLER_3_538 VGND VGND VPWR VPWR sky130_fd_sc_hd__decap_3
XFILLER_105_455 VGND VGND VPWR VPWR sky130_fd_sc_hd__decap_3
XFILLER_78_306 VGND VGND VPWR VPWR sky130_fd_sc_hd__fill_2
XFILLER_87_37 VGND VGND VPWR VPWR sky130_fd_sc_hd__fill_2
XFILLER_59_520 VGND VGND VPWR VPWR sky130_fd_sc_hd__decap_3
XTAP_TAPCELL_ROW_70_1130 VGND VPWR sky130_fd_sc_hd__tapvpwrvgnd_1
XTAP_TAPCELL_ROW_6_332 VGND VPWR sky130_fd_sc_hd__tapvpwrvgnd_1
XFILLER_101_650 VGND VGND VPWR VPWR sky130_fd_sc_hd__decap_3
XFILLER_101_694 VGND VGND VPWR VPWR sky130_fd_sc_hd__decap_3
XFILLER_19_439 VGND VGND VPWR VPWR sky130_fd_sc_hd__fill_1
XFILLER_46_203 VGND VGND VPWR VPWR sky130_fd_sc_hd__decap_3
XFILLER_86_372 VGND VGND VPWR VPWR sky130_fd_sc_hd__decap_3
XTAP_TAPCELL_ROW_109_1616 VGND VPWR sky130_fd_sc_hd__tapvpwrvgnd_1
XFILLER_100_171 VGND VGND VPWR VPWR sky130_fd_sc_hd__decap_3
XFILLER_100_193 VGND VGND VPWR VPWR sky130_fd_sc_hd__decap_3
XFILLER_62_707 VGND VGND VPWR VPWR sky130_fd_sc_hd__decap_3
XFILLER_74_567 VGND VGND VPWR VPWR sky130_fd_sc_hd__decap_3
XFILLER_14_100 VGND VGND VPWR VPWR sky130_fd_sc_hd__decap_3
XFILLER_15_623 VGND VGND VPWR VPWR sky130_fd_sc_hd__decap_3
XFILLER_36_85 VGND VGND VPWR VPWR sky130_fd_sc_hd__fill_2
XFILLER_61_239 VGND VGND VPWR VPWR sky130_fd_sc_hd__decap_3
XFILLER_14_144 VGND VGND VPWR VPWR sky130_fd_sc_hd__decap_3
XFILLER_15_656 VGND VGND VPWR VPWR sky130_fd_sc_hd__decap_3
XFILLER_30_604 VGND VGND VPWR VPWR sky130_fd_sc_hd__decap_3
XFILLER_30_637 VGND VGND VPWR VPWR sky130_fd_sc_hd__decap_3
XFILLER_42_475 VGND VGND VPWR VPWR sky130_fd_sc_hd__fill_1
XTAP_TAPCELL_ROW_81_1270 VGND VPWR sky130_fd_sc_hd__tapvpwrvgnd_1
XFILLER_30_648 VGND VGND VPWR VPWR sky130_fd_sc_hd__decap_3
XFILLER_52_73 VGND VGND VPWR VPWR sky130_fd_sc_hd__fill_1
XFILLER_10_361 VGND VGND VPWR VPWR sky130_fd_sc_hd__decap_3
XFILLER_10_383 VGND VGND VPWR VPWR sky130_fd_sc_hd__decap_3
XFILLER_6_321 VGND VGND VPWR VPWR sky130_fd_sc_hd__decap_3
XFILLER_108_271 VGND VGND VPWR VPWR sky130_fd_sc_hd__fill_2
XFILLER_6_365 VGND VGND VPWR VPWR sky130_fd_sc_hd__decap_3
XFILLER_2_560 VGND VGND VPWR VPWR sky130_fd_sc_hd__decap_3
XFILLER_69_317 VGND VGND VPWR VPWR sky130_fd_sc_hd__decap_3
XFILLER_97_604 VGND VGND VPWR VPWR sky130_fd_sc_hd__fill_1
XFILLER_97_626 VGND VGND VPWR VPWR sky130_fd_sc_hd__decap_3
XFILLER_96_125 VGND VGND VPWR VPWR sky130_fd_sc_hd__decap_3
XFILLER_97_659 VGND VGND VPWR VPWR sky130_fd_sc_hd__decap_3
XFILLER_111_447 VGND VGND VPWR VPWR sky130_fd_sc_hd__fill_1
XFILLER_111_469 VGND VGND VPWR VPWR sky130_fd_sc_hd__decap_3
XFILLER_38_704 VGND VGND VPWR VPWR sky130_fd_sc_hd__decap_3
XFILLER_77_70 VGND VGND VPWR VPWR sky130_fd_sc_hd__decap_3
XFILLER_84_309 VGND VGND VPWR VPWR sky130_fd_sc_hd__fill_1
XFILLER_96_147 VGND VGND VPWR VPWR sky130_fd_sc_hd__decap_3
XFILLER_37_203 VGND VGND VPWR VPWR sky130_fd_sc_hd__decap_3
XFILLER_65_523 VGND VGND VPWR VPWR sky130_fd_sc_hd__decap_3
XFILLER_77_361 VGND VGND VPWR VPWR sky130_fd_sc_hd__decap_3
XFILLER_37_236 VGND VGND VPWR VPWR sky130_fd_sc_hd__decap_3
XFILLER_18_450 VGND VGND VPWR VPWR sky130_fd_sc_hd__decap_3
XFILLER_80_504 VGND VGND VPWR VPWR sky130_fd_sc_hd__decap_3
XFILLER_52_239 VGND VGND VPWR VPWR sky130_fd_sc_hd__decap_3
X_4911_ _6997_/Q _4931_/A VGND VGND VPWR VPWR _4912_/B sky130_fd_sc_hd__nor2_2
XFILLER_33_464 VGND VGND VPWR VPWR sky130_fd_sc_hd__decap_3
XFILLER_45_291 VGND VGND VPWR VPWR sky130_fd_sc_hd__decap_3
XFILLER_20_114 VGND VGND VPWR VPWR sky130_fd_sc_hd__decap_3
XFILLER_21_615 VGND VGND VPWR VPWR sky130_fd_sc_hd__fill_1
XFILLER_21_626 VGND VGND VPWR VPWR sky130_fd_sc_hd__decap_3
XFILLER_33_486 VGND VGND VPWR VPWR sky130_fd_sc_hd__decap_3
XFILLER_60_250 VGND VGND VPWR VPWR sky130_fd_sc_hd__fill_2
X_4842_ _4643_/Y _4841_/Y _4845_/A VGND VGND VPWR VPWR _4842_/X sky130_fd_sc_hd__a21o_2
XFILLER_20_147 VGND VGND VPWR VPWR sky130_fd_sc_hd__decap_3
XFILLER_21_659 VGND VGND VPWR VPWR sky130_fd_sc_hd__decap_3
XFILLER_60_294 VGND VGND VPWR VPWR sky130_fd_sc_hd__decap_3
XTAP_TAPCELL_ROW_31_643 VGND VPWR sky130_fd_sc_hd__tapvpwrvgnd_1
XFILLER_119_525 VGND VGND VPWR VPWR sky130_fd_sc_hd__decap_3
XFILLER_119_536 VGND VGND VPWR VPWR sky130_fd_sc_hd__fill_2
X_6512_ _6639_/A VGND VGND VPWR VPWR _6512_/Y sky130_fd_sc_hd__inv_2
X_3724_ _6828_/Q _3892_/A2 _3913_/A2 _6818_/Q _3723_/X VGND VGND VPWR VPWR _3724_/X
+ sky130_fd_sc_hd__a221o_2
XFILLER_107_709 VGND VGND VPWR VPWR sky130_fd_sc_hd__decap_3
X_6443_ _6636_/A VGND VGND VPWR VPWR _6443_/Y sky130_fd_sc_hd__inv_2
X_6374_ _6635_/A VGND VGND VPWR VPWR _6374_/Y sky130_fd_sc_hd__inv_2
X_3586_ _3591_/A _3591_/B _3591_/C _3586_/D VGND VGND VPWR VPWR _3586_/Y sky130_fd_sc_hd__nor4_2
XFILLER_0_508 VGND VGND VPWR VPWR sky130_fd_sc_hd__decap_3
XFILLER_114_241 VGND VGND VPWR VPWR sky130_fd_sc_hd__fill_2
XFILLER_88_615 VGND VGND VPWR VPWR sky130_fd_sc_hd__decap_3
X_5325_ _5325_/A0 _4964_/X _5340_/S VGND VGND VPWR VPWR _7168_/D sky130_fd_sc_hd__mux2_2
XFILLER_87_103 VGND VGND VPWR VPWR sky130_fd_sc_hd__decap_3
XFILLER_87_125 VGND VGND VPWR VPWR sky130_fd_sc_hd__decap_3
XFILLER_88_648 VGND VGND VPWR VPWR sky130_fd_sc_hd__decap_3
X_5256_ _5256_/A0 _4932_/X _5274_/S VGND VGND VPWR VPWR _7202_/D sky130_fd_sc_hd__mux2_2
XFILLER_102_447 VGND VGND VPWR VPWR sky130_fd_sc_hd__fill_2
XFILLER_102_458 VGND VGND VPWR VPWR sky130_fd_sc_hd__decap_3
XFILLER_87_169 VGND VGND VPWR VPWR sky130_fd_sc_hd__decap_3
X_4207_ _4207_/A _4642_/B VGND VGND VPWR VPWR _4208_/B sky130_fd_sc_hd__and2_2
XFILLER_28_203 VGND VGND VPWR VPWR sky130_fd_sc_hd__decap_3
XFILLER_56_512 VGND VGND VPWR VPWR sky130_fd_sc_hd__decap_3
XFILLER_68_350 VGND VGND VPWR VPWR sky130_fd_sc_hd__decap_3
XFILLER_96_681 VGND VGND VPWR VPWR sky130_fd_sc_hd__decap_3
XFILLER_113_35 VGND VGND VPWR VPWR sky130_fd_sc_hd__decap_3
XFILLER_83_331 VGND VGND VPWR VPWR sky130_fd_sc_hd__decap_3
X_4138_ _4134_/X _4137_/X _4425_/A VGND VGND VPWR VPWR _4642_/B sky130_fd_sc_hd__o21a_2
XTAP_TAPCELL_ROW_39_743 VGND VPWR sky130_fd_sc_hd__tapvpwrvgnd_1
XFILLER_113_57 VGND VGND VPWR VPWR sky130_fd_sc_hd__decap_3
XFILLER_44_707 VGND VGND VPWR VPWR sky130_fd_sc_hd__decap_3
XFILLER_83_353 VGND VGND VPWR VPWR sky130_fd_sc_hd__decap_3
XFILLER_83_364 VGND VGND VPWR VPWR sky130_fd_sc_hd__decap_3
X_4069_ _4744_/B _4069_/B VGND VGND VPWR VPWR _4610_/A sky130_fd_sc_hd__nor2_2
XFILLER_43_217 VGND VGND VPWR VPWR sky130_fd_sc_hd__decap_3
XFILLER_43_228 VGND VGND VPWR VPWR sky130_fd_sc_hd__decap_3
XFILLER_12_604 VGND VGND VPWR VPWR sky130_fd_sc_hd__decap_3
XFILLER_36_291 VGND VGND VPWR VPWR sky130_fd_sc_hd__decap_3
XTAP_TAPCELL_ROW_104_1557 VGND VPWR sky130_fd_sc_hd__tapvpwrvgnd_1
XFILLER_12_637 VGND VGND VPWR VPWR sky130_fd_sc_hd__decap_3
XFILLER_24_486 VGND VGND VPWR VPWR sky130_fd_sc_hd__decap_3
XFILLER_51_261 VGND VGND VPWR VPWR sky130_fd_sc_hd__decap_3
XFILLER_12_648 VGND VGND VPWR VPWR sky130_fd_sc_hd__decap_3
XFILLER_8_619 VGND VGND VPWR VPWR sky130_fd_sc_hd__decap_3
XFILLER_11_169 VGND VGND VPWR VPWR sky130_fd_sc_hd__fill_1
XFILLER_22_43 VGND VGND VPWR VPWR sky130_fd_sc_hd__decap_3
XFILLER_7_129 VGND VGND VPWR VPWR sky130_fd_sc_hd__decap_3
XFILLER_20_681 VGND VGND VPWR VPWR sky130_fd_sc_hd__decap_3
XFILLER_22_65 VGND VGND VPWR VPWR sky130_fd_sc_hd__decap_3
XFILLER_3_346 VGND VGND VPWR VPWR sky130_fd_sc_hd__decap_3
XFILLER_3_379 VGND VGND VPWR VPWR sky130_fd_sc_hd__decap_3
XFILLER_79_615 VGND VGND VPWR VPWR sky130_fd_sc_hd__fill_1
XFILLER_105_274 VGND VGND VPWR VPWR sky130_fd_sc_hd__decap_3
XFILLER_78_103 VGND VGND VPWR VPWR sky130_fd_sc_hd__decap_3
XFILLER_79_626 VGND VGND VPWR VPWR sky130_fd_sc_hd__decap_3
XFILLER_79_659 VGND VGND VPWR VPWR sky130_fd_sc_hd__decap_3
XTAP_TAPCELL_ROW_115_1697 VGND VPWR sky130_fd_sc_hd__tapvpwrvgnd_1
XFILLER_66_309 VGND VGND VPWR VPWR sky130_fd_sc_hd__decap_3
XFILLER_78_136 VGND VGND VPWR VPWR sky130_fd_sc_hd__decap_3
XFILLER_78_147 VGND VGND VPWR VPWR sky130_fd_sc_hd__decap_3
XFILLER_78_169 VGND VGND VPWR VPWR sky130_fd_sc_hd__decap_3
XFILLER_47_501 VGND VGND VPWR VPWR sky130_fd_sc_hd__decap_3
XFILLER_59_361 VGND VGND VPWR VPWR sky130_fd_sc_hd__decap_3
XFILLER_59_383 VGND VGND VPWR VPWR sky130_fd_sc_hd__decap_3
XFILLER_87_670 VGND VGND VPWR VPWR sky130_fd_sc_hd__fill_2
XFILLER_93_128 VGND VGND VPWR VPWR sky130_fd_sc_hd__decap_3
XFILLER_101_491 VGND VGND VPWR VPWR sky130_fd_sc_hd__decap_3
XFILLER_19_225 VGND VGND VPWR VPWR sky130_fd_sc_hd__decap_3
XFILLER_47_534 VGND VGND VPWR VPWR sky130_fd_sc_hd__decap_3
XFILLER_86_180 VGND VGND VPWR VPWR sky130_fd_sc_hd__decap_3
XFILLER_34_217 VGND VGND VPWR VPWR sky130_fd_sc_hd__decap_3
XFILLER_15_431 VGND VGND VPWR VPWR sky130_fd_sc_hd__decap_3
XFILLER_15_464 VGND VGND VPWR VPWR sky130_fd_sc_hd__fill_1
XFILLER_42_250 VGND VGND VPWR VPWR sky130_fd_sc_hd__fill_2
XFILLER_70_592 VGND VGND VPWR VPWR sky130_fd_sc_hd__decap_3
XFILLER_30_489 VGND VGND VPWR VPWR sky130_fd_sc_hd__decap_3
XFILLER_7_641 VGND VGND VPWR VPWR sky130_fd_sc_hd__decap_3
XFILLER_6_162 VGND VGND VPWR VPWR sky130_fd_sc_hd__fill_1
XFILLER_7_685 VGND VGND VPWR VPWR sky130_fd_sc_hd__decap_3
X_3440_ _7250_/Q _4599_/S _3434_/X _3439_/X VGND VGND VPWR VPWR _3440_/X sky130_fd_sc_hd__a211o_2
XFILLER_112_701 VGND VGND VPWR VPWR sky130_fd_sc_hd__decap_3
X_3371_ _3371_/A _5118_/D _5118_/A _6979_/Q VGND VGND VPWR VPWR _3371_/Y sky130_fd_sc_hd__nor4bb_2
XFILLER_88_91 VGND VGND VPWR VPWR sky130_fd_sc_hd__decap_3
XFILLER_97_412 VGND VGND VPWR VPWR sky130_fd_sc_hd__decap_3
XFILLER_97_434 VGND VGND VPWR VPWR sky130_fd_sc_hd__decap_3
X_5110_ _3610_/A _3603_/Y _4292_/C VGND VGND VPWR VPWR _5110_/Y sky130_fd_sc_hd__a21oi_2
XFILLER_111_244 VGND VGND VPWR VPWR sky130_fd_sc_hd__decap_3
XFILLER_69_158 VGND VGND VPWR VPWR sky130_fd_sc_hd__fill_2
XFILLER_85_607 VGND VGND VPWR VPWR sky130_fd_sc_hd__fill_1
X_5041_ _5041_/A0 _5040_/X _5159_/S VGND VGND VPWR VPWR _7259_/D sky130_fd_sc_hd__mux2_2
XFILLER_111_277 VGND VGND VPWR VPWR sky130_fd_sc_hd__decap_3
XFILLER_69_169 VGND VGND VPWR VPWR sky130_fd_sc_hd__decap_3
XFILLER_78_681 VGND VGND VPWR VPWR sky130_fd_sc_hd__decap_3
XFILLER_84_106 VGND VGND VPWR VPWR sky130_fd_sc_hd__decap_3
XFILLER_85_629 VGND VGND VPWR VPWR sky130_fd_sc_hd__decap_3
XFILLER_97_489 VGND VGND VPWR VPWR sky130_fd_sc_hd__decap_3
Xhold1308 _7230_/Q VGND VGND VPWR VPWR _5196_/A sky130_fd_sc_hd__dlygate4sd3_1
Xhold1319 _6704_/Q VGND VGND VPWR VPWR _5708_/A1 sky130_fd_sc_hd__dlygate4sd3_1
XFILLER_111_299 VGND VGND VPWR VPWR sky130_fd_sc_hd__fill_1
XFILLER_84_139 VGND VGND VPWR VPWR sky130_fd_sc_hd__fill_1
XFILLER_26_707 VGND VGND VPWR VPWR sky130_fd_sc_hd__decap_3
XFILLER_38_589 VGND VGND VPWR VPWR sky130_fd_sc_hd__decap_3
XFILLER_92_150 VGND VGND VPWR VPWR sky130_fd_sc_hd__decap_3
XFILLER_93_662 VGND VGND VPWR VPWR sky130_fd_sc_hd__decap_3
XFILLER_93_673 VGND VGND VPWR VPWR sky130_fd_sc_hd__decap_3
XTAP_TAPCELL_ROW_36_702 VGND VPWR sky130_fd_sc_hd__tapvpwrvgnd_1
XFILLER_80_312 VGND VGND VPWR VPWR sky130_fd_sc_hd__decap_3
XFILLER_92_183 VGND VGND VPWR VPWR sky130_fd_sc_hd__decap_3
X_6992_ _7396_/CLK _6992_/D _6272_/Y VGND VGND VPWR VPWR _6992_/Q sky130_fd_sc_hd__dfrtp_2
XTAP_TAPCELL_ROW_36_713 VGND VPWR sky130_fd_sc_hd__tapvpwrvgnd_1
XFILLER_21_412 VGND VGND VPWR VPWR sky130_fd_sc_hd__decap_3
XFILLER_40_209 VGND VGND VPWR VPWR sky130_fd_sc_hd__decap_3
XFILLER_61_570 VGND VGND VPWR VPWR sky130_fd_sc_hd__decap_3
XFILLER_80_389 VGND VGND VPWR VPWR sky130_fd_sc_hd__decap_3
XFILLER_21_434 VGND VGND VPWR VPWR sky130_fd_sc_hd__decap_3
X_4825_ _7001_/Q _4825_/B VGND VGND VPWR VPWR _4826_/B sky130_fd_sc_hd__nor2_2
X_4687_ _7001_/Q _4687_/B VGND VGND VPWR VPWR _4834_/A sky130_fd_sc_hd__and2_2
X_3707_ _6937_/Q _3760_/A2 _3767_/B1 _6889_/Q VGND VGND VPWR VPWR _3707_/X sky130_fd_sc_hd__a22o_2
XFILLER_107_539 VGND VGND VPWR VPWR sky130_fd_sc_hd__decap_3
XFILLER_108_24 VGND VGND VPWR VPWR sky130_fd_sc_hd__decap_3
XFILLER_108_35 VGND VGND VPWR VPWR sky130_fd_sc_hd__decap_3
X_6426_ _6683_/A VGND VGND VPWR VPWR _6426_/Y sky130_fd_sc_hd__inv_2
X_3638_ _3635_/A _3618_/C _3547_/A VGND VGND VPWR VPWR _3638_/X sky130_fd_sc_hd__a21bo_2
XFILLER_108_68 VGND VGND VPWR VPWR sky130_fd_sc_hd__decap_3
XFILLER_115_561 VGND VGND VPWR VPWR sky130_fd_sc_hd__fill_2
XFILLER_88_401 VGND VGND VPWR VPWR sky130_fd_sc_hd__decap_3
X_6357_ _6649_/A VGND VGND VPWR VPWR _6357_/Y sky130_fd_sc_hd__inv_2
X_3569_ _7285_/Q _5159_/S _3567_/X _3568_/X VGND VGND VPWR VPWR _3569_/X sky130_fd_sc_hd__a211o_2
XFILLER_103_712 VGND VGND VPWR VPWR sky130_fd_sc_hd__fill_2
XFILLER_115_572 VGND VGND VPWR VPWR sky130_fd_sc_hd__decap_3
X_5308_ _5308_/A0 _4822_/X _5323_/S VGND VGND VPWR VPWR _7176_/D sky130_fd_sc_hd__mux2_2
XFILLER_102_222 VGND VGND VPWR VPWR sky130_fd_sc_hd__decap_3
XFILLER_88_445 VGND VGND VPWR VPWR sky130_fd_sc_hd__fill_1
X_6288_ _6288_/A VGND VGND VPWR VPWR _6288_/Y sky130_fd_sc_hd__inv_2
XFILLER_102_277 VGND VGND VPWR VPWR sky130_fd_sc_hd__decap_3
XFILLER_29_501 VGND VGND VPWR VPWR sky130_fd_sc_hd__decap_3
XFILLER_48_309 VGND VGND VPWR VPWR sky130_fd_sc_hd__decap_3
XFILLER_75_106 VGND VGND VPWR VPWR sky130_fd_sc_hd__decap_3
XFILLER_76_618 VGND VGND VPWR VPWR sky130_fd_sc_hd__decap_3
XFILLER_88_489 VGND VGND VPWR VPWR sky130_fd_sc_hd__decap_3
X_5239_ _5239_/A1 _5238_/X _4766_/A VGND VGND VPWR VPWR _7211_/D sky130_fd_sc_hd__a21o_2
XFILLER_102_299 VGND VGND VPWR VPWR sky130_fd_sc_hd__fill_2
XFILLER_68_180 VGND VGND VPWR VPWR sky130_fd_sc_hd__decap_3
XFILLER_84_640 VGND VGND VPWR VPWR sky130_fd_sc_hd__decap_3
XFILLER_16_206 VGND VGND VPWR VPWR sky130_fd_sc_hd__fill_2
XFILLER_17_21 VGND VGND VPWR VPWR sky130_fd_sc_hd__fill_2
XFILLER_29_567 VGND VGND VPWR VPWR sky130_fd_sc_hd__decap_3
XFILLER_56_342 VGND VGND VPWR VPWR sky130_fd_sc_hd__fill_2
XFILLER_56_353 VGND VGND VPWR VPWR sky130_fd_sc_hd__decap_3
XFILLER_83_150 VGND VGND VPWR VPWR sky130_fd_sc_hd__decap_3
XFILLER_84_651 VGND VGND VPWR VPWR sky130_fd_sc_hd__decap_3
XFILLER_90_109 VGND VGND VPWR VPWR sky130_fd_sc_hd__decap_3
XFILLER_16_228 VGND VGND VPWR VPWR sky130_fd_sc_hd__fill_2
XFILLER_16_239 VGND VGND VPWR VPWR sky130_fd_sc_hd__fill_1
XFILLER_17_54 VGND VGND VPWR VPWR sky130_fd_sc_hd__fill_2
XFILLER_71_334 VGND VGND VPWR VPWR sky130_fd_sc_hd__fill_2
XFILLER_83_172 VGND VGND VPWR VPWR sky130_fd_sc_hd__decap_3
XFILLER_84_684 VGND VGND VPWR VPWR sky130_fd_sc_hd__decap_3
XFILLER_17_87 VGND VGND VPWR VPWR sky130_fd_sc_hd__decap_3
XFILLER_44_559 VGND VGND VPWR VPWR sky130_fd_sc_hd__decap_3
XFILLER_40_710 VGND VGND VPWR VPWR sky130_fd_sc_hd__decap_3
XTAP_TAPCELL_ROW_65_1073 VGND VPWR sky130_fd_sc_hd__tapvpwrvgnd_1
XFILLER_12_434 VGND VGND VPWR VPWR sky130_fd_sc_hd__fill_2
XFILLER_33_20 VGND VGND VPWR VPWR sky130_fd_sc_hd__decap_3
XTAP_TAPCELL_ROW_14_429 VGND VPWR sky130_fd_sc_hd__tapvpwrvgnd_1
XFILLER_12_467 VGND VGND VPWR VPWR sky130_fd_sc_hd__decap_3
XFILLER_8_416 VGND VGND VPWR VPWR sky130_fd_sc_hd__decap_3
XFILLER_12_489 VGND VGND VPWR VPWR sky130_fd_sc_hd__decap_3
XTAP_TAPCELL_ROW_117_1726 VGND VPWR sky130_fd_sc_hd__tapvpwrvgnd_1
XTAP_TAPCELL_ROW_117_1715 VGND VPWR sky130_fd_sc_hd__tapvpwrvgnd_1
XFILLER_4_611 VGND VGND VPWR VPWR sky130_fd_sc_hd__decap_3
XFILLER_4_666 VGND VGND VPWR VPWR sky130_fd_sc_hd__decap_3
XFILLER_4_699 VGND VGND VPWR VPWR sky130_fd_sc_hd__fill_1
XFILLER_58_83 VGND VGND VPWR VPWR sky130_fd_sc_hd__fill_1
XFILLER_67_629 VGND VGND VPWR VPWR sky130_fd_sc_hd__decap_3
XFILLER_94_404 VGND VGND VPWR VPWR sky130_fd_sc_hd__decap_3
XFILLER_47_331 VGND VGND VPWR VPWR sky130_fd_sc_hd__fill_1
XFILLER_47_364 VGND VGND VPWR VPWR sky130_fd_sc_hd__decap_3
XFILLER_74_150 VGND VGND VPWR VPWR sky130_fd_sc_hd__decap_3
XFILLER_75_662 VGND VGND VPWR VPWR sky130_fd_sc_hd__decap_3
XFILLER_75_673 VGND VGND VPWR VPWR sky130_fd_sc_hd__decap_3
XFILLER_81_109 VGND VGND VPWR VPWR sky130_fd_sc_hd__decap_3
XFILLER_62_323 VGND VGND VPWR VPWR sky130_fd_sc_hd__fill_2
XFILLER_74_183 VGND VGND VPWR VPWR sky130_fd_sc_hd__decap_3
XFILLER_50_507 VGND VGND VPWR VPWR sky130_fd_sc_hd__decap_3
XFILLER_74_71 VGND VGND VPWR VPWR sky130_fd_sc_hd__decap_3
XFILLER_90_643 VGND VGND VPWR VPWR sky130_fd_sc_hd__fill_1
XFILLER_90_654 VGND VGND VPWR VPWR sky130_fd_sc_hd__decap_3
XFILLER_62_389 VGND VGND VPWR VPWR sky130_fd_sc_hd__decap_3
XFILLER_90_687 VGND VGND VPWR VPWR sky130_fd_sc_hd__decap_3
XFILLER_30_220 VGND VGND VPWR VPWR sky130_fd_sc_hd__decap_3
XFILLER_30_253 VGND VGND VPWR VPWR sky130_fd_sc_hd__decap_3
XFILLER_90_70 VGND VGND VPWR VPWR sky130_fd_sc_hd__decap_3
X_4610_ _4610_/A _4762_/B VGND VGND VPWR VPWR _4611_/A sky130_fd_sc_hd__nand2_2
XFILLER_30_275 VGND VGND VPWR VPWR sky130_fd_sc_hd__decap_3
XTAP_TAPCELL_ROW_41_771 VGND VPWR sky130_fd_sc_hd__tapvpwrvgnd_1
XFILLER_7_493 VGND VGND VPWR VPWR sky130_fd_sc_hd__fill_2
X_7260_ _7357_/CLK _7260_/D _6540_/Y VGND VGND VPWR VPWR _7260_/Q sky130_fd_sc_hd__dfrtp_2
XTAP_TAPCELL_ROW_92_1409 VGND VPWR sky130_fd_sc_hd__tapvpwrvgnd_1
X_7191_ _7387_/CLK _7191_/D _6471_/Y VGND VGND VPWR VPWR _7191_/Q sky130_fd_sc_hd__dfrtp_2
X_3423_ _3442_/A _3442_/B _3423_/C VGND VGND VPWR VPWR _3424_/S sky130_fd_sc_hd__and3_4
XFILLER_98_710 VGND VGND VPWR VPWR sky130_fd_sc_hd__decap_3
XFILLER_97_231 VGND VGND VPWR VPWR sky130_fd_sc_hd__fill_1
X_3354_ _3371_/A _5668_/A _3328_/B _5670_/A VGND VGND VPWR VPWR _3354_/X sky130_fd_sc_hd__a211o_2
XFILLER_100_704 VGND VGND VPWR VPWR sky130_fd_sc_hd__decap_3
XFILLER_112_586 VGND VGND VPWR VPWR sky130_fd_sc_hd__fill_2
XFILLER_85_426 VGND VGND VPWR VPWR sky130_fd_sc_hd__decap_3
XFILLER_97_253 VGND VGND VPWR VPWR sky130_fd_sc_hd__decap_3
Xhold1105 _7214_/Q VGND VGND VPWR VPWR _5232_/A0 sky130_fd_sc_hd__dlygate4sd3_1
Xhold1116 _7269_/Q VGND VGND VPWR VPWR _4879_/A0 sky130_fd_sc_hd__dlygate4sd3_1
Xhold1127 _7379_/Q VGND VGND VPWR VPWR _3909_/A1 sky130_fd_sc_hd__dlygate4sd3_1
Xhold1138 _7404_/Q VGND VGND VPWR VPWR _3684_/A1 sky130_fd_sc_hd__dlygate4sd3_1
Xhold1149 _7213_/Q VGND VGND VPWR VPWR _5234_/A0 sky130_fd_sc_hd__dlygate4sd3_1
X_5024_ _3864_/S _3832_/X _5015_/X _5023_/Y VGND VGND VPWR VPWR _5024_/X sky130_fd_sc_hd__a211o_2
XFILLER_26_504 VGND VGND VPWR VPWR sky130_fd_sc_hd__decap_3
XFILLER_38_342 VGND VGND VPWR VPWR sky130_fd_sc_hd__decap_3
XFILLER_66_651 VGND VGND VPWR VPWR sky130_fd_sc_hd__decap_3
XFILLER_65_161 VGND VGND VPWR VPWR sky130_fd_sc_hd__decap_3
XFILLER_65_172 VGND VGND VPWR VPWR sky130_fd_sc_hd__decap_3
XFILLER_66_684 VGND VGND VPWR VPWR sky130_fd_sc_hd__decap_3
XFILLER_81_632 VGND VGND VPWR VPWR sky130_fd_sc_hd__decap_3
XTAP_TAPCELL_ROW_49_871 VGND VPWR sky130_fd_sc_hd__tapvpwrvgnd_1
XFILLER_65_194 VGND VGND VPWR VPWR sky130_fd_sc_hd__fill_2
XFILLER_81_665 VGND VGND VPWR VPWR sky130_fd_sc_hd__decap_3
X_6975_ clkload5/A _6975_/D VGND VGND VPWR VPWR _6975_/Q sky130_fd_sc_hd__dfxtp_2
XFILLER_110_14 VGND VGND VPWR VPWR sky130_fd_sc_hd__decap_3
XFILLER_22_710 VGND VGND VPWR VPWR sky130_fd_sc_hd__decap_3
XFILLER_41_518 VGND VGND VPWR VPWR sky130_fd_sc_hd__decap_3
XFILLER_53_367 VGND VGND VPWR VPWR sky130_fd_sc_hd__decap_3
XFILLER_80_164 VGND VGND VPWR VPWR sky130_fd_sc_hd__decap_3
XFILLER_81_676 VGND VGND VPWR VPWR sky130_fd_sc_hd__decap_3
XFILLER_110_47 VGND VGND VPWR VPWR sky130_fd_sc_hd__decap_3
XFILLER_34_581 VGND VGND VPWR VPWR sky130_fd_sc_hd__decap_3
XFILLER_34_592 VGND VGND VPWR VPWR sky130_fd_sc_hd__decap_3
XFILLER_80_186 VGND VGND VPWR VPWR sky130_fd_sc_hd__decap_3
XFILLER_80_197 VGND VGND VPWR VPWR sky130_fd_sc_hd__decap_3
XTAP_TAPCELL_ROW_101_1516 VGND VPWR sky130_fd_sc_hd__tapvpwrvgnd_1
XFILLER_21_231 VGND VGND VPWR VPWR sky130_fd_sc_hd__decap_3
XFILLER_70_29 VGND VGND VPWR VPWR sky130_fd_sc_hd__decap_3
XFILLER_21_275 VGND VGND VPWR VPWR sky130_fd_sc_hd__fill_1
XFILLER_119_141 VGND VGND VPWR VPWR sky130_fd_sc_hd__decap_3
XFILLER_119_45 VGND VGND VPWR VPWR sky130_fd_sc_hd__decap_3
X_4739_ _4762_/A _4762_/B _4765_/B _4610_/A VGND VGND VPWR VPWR _4739_/Y sky130_fd_sc_hd__a211oi_2
XFILLER_119_78 VGND VGND VPWR VPWR sky130_fd_sc_hd__decap_3
XFILLER_79_27 VGND VGND VPWR VPWR sky130_fd_sc_hd__decap_3
XFILLER_107_358 VGND VGND VPWR VPWR sky130_fd_sc_hd__decap_3
X_6409_ _6640_/A VGND VGND VPWR VPWR _6409_/Y sky130_fd_sc_hd__inv_2
XFILLER_1_603 VGND VGND VPWR VPWR sky130_fd_sc_hd__decap_3
X_7389_ _7390_/CLK _7389_/D _6669_/Y VGND VGND VPWR VPWR _7389_/Q sky130_fd_sc_hd__dfrtp_2
Xhold950 _7114_/Q VGND VGND VPWR VPWR _7114_/D sky130_fd_sc_hd__dlygate4sd3_1
Xhold961 _7118_/Q VGND VGND VPWR VPWR _7118_/D sky130_fd_sc_hd__dlygate4sd3_1
Xhold972 _7102_/Q VGND VGND VPWR VPWR _7102_/D sky130_fd_sc_hd__dlygate4sd3_1
XFILLER_0_113 VGND VGND VPWR VPWR sky130_fd_sc_hd__fill_2
XFILLER_103_520 VGND VGND VPWR VPWR sky130_fd_sc_hd__decap_3
XFILLER_115_391 VGND VGND VPWR VPWR sky130_fd_sc_hd__fill_1
XFILLER_1_647 VGND VGND VPWR VPWR sky130_fd_sc_hd__decap_3
XFILLER_88_242 VGND VGND VPWR VPWR sky130_fd_sc_hd__decap_3
Xhold983 _7077_/Q VGND VGND VPWR VPWR _7077_/D sky130_fd_sc_hd__dlygate4sd3_1
Xhold994 _7097_/Q VGND VGND VPWR VPWR _7097_/D sky130_fd_sc_hd__dlygate4sd3_1
XTAP_TAPCELL_ROW_112_1656 VGND VPWR sky130_fd_sc_hd__tapvpwrvgnd_1
XFILLER_49_629 VGND VGND VPWR VPWR sky130_fd_sc_hd__decap_3
XFILLER_76_404 VGND VGND VPWR VPWR sky130_fd_sc_hd__fill_1
XFILLER_88_253 VGND VGND VPWR VPWR sky130_fd_sc_hd__decap_3
XFILLER_48_139 VGND VGND VPWR VPWR sky130_fd_sc_hd__fill_1
XFILLER_76_459 VGND VGND VPWR VPWR sky130_fd_sc_hd__decap_3
XFILLER_88_286 VGND VGND VPWR VPWR sky130_fd_sc_hd__decap_3
XFILLER_29_331 VGND VGND VPWR VPWR sky130_fd_sc_hd__decap_3
XFILLER_29_364 VGND VGND VPWR VPWR sky130_fd_sc_hd__decap_3
XFILLER_57_662 VGND VGND VPWR VPWR sky130_fd_sc_hd__decap_3
XFILLER_57_673 VGND VGND VPWR VPWR sky130_fd_sc_hd__decap_3
XFILLER_91_418 VGND VGND VPWR VPWR sky130_fd_sc_hd__decap_3
XFILLER_17_526 VGND VGND VPWR VPWR sky130_fd_sc_hd__fill_1
XFILLER_44_312 VGND VGND VPWR VPWR sky130_fd_sc_hd__decap_3
XFILLER_56_150 VGND VGND VPWR VPWR sky130_fd_sc_hd__decap_3
XFILLER_72_610 VGND VGND VPWR VPWR sky130_fd_sc_hd__decap_3
XFILLER_72_643 VGND VGND VPWR VPWR sky130_fd_sc_hd__fill_1
XFILLER_72_654 VGND VGND VPWR VPWR sky130_fd_sc_hd__decap_3
XFILLER_71_153 VGND VGND VPWR VPWR sky130_fd_sc_hd__decap_3
XFILLER_71_175 VGND VGND VPWR VPWR sky130_fd_sc_hd__decap_3
XFILLER_72_687 VGND VGND VPWR VPWR sky130_fd_sc_hd__decap_3
XFILLER_25_592 VGND VGND VPWR VPWR sky130_fd_sc_hd__decap_3
XFILLER_44_74 VGND VGND VPWR VPWR sky130_fd_sc_hd__fill_2
XFILLER_44_85 VGND VGND VPWR VPWR sky130_fd_sc_hd__decap_3
XTAP_TAPCELL_ROW_27_598 VGND VPWR sky130_fd_sc_hd__tapvpwrvgnd_1
XFILLER_12_231 VGND VGND VPWR VPWR sky130_fd_sc_hd__fill_2
XFILLER_12_242 VGND VGND VPWR VPWR sky130_fd_sc_hd__decap_3
XFILLER_12_253 VGND VGND VPWR VPWR sky130_fd_sc_hd__fill_1
XFILLER_40_551 VGND VGND VPWR VPWR sky130_fd_sc_hd__decap_3
XFILLER_9_703 VGND VGND VPWR VPWR sky130_fd_sc_hd__decap_3
XFILLER_100_80 VGND VGND VPWR VPWR sky130_fd_sc_hd__decap_3
XFILLER_100_91 VGND VGND VPWR VPWR sky130_fd_sc_hd__decap_3
XFILLER_12_275 VGND VGND VPWR VPWR sky130_fd_sc_hd__decap_3
XFILLER_60_62 VGND VGND VPWR VPWR sky130_fd_sc_hd__fill_2
XTAP_TAPCELL_ROW_78_1231 VGND VPWR sky130_fd_sc_hd__tapvpwrvgnd_1
XFILLER_4_452 VGND VGND VPWR VPWR sky130_fd_sc_hd__decap_3
XFILLER_99_529 VGND VGND VPWR VPWR sky130_fd_sc_hd__decap_3
XFILLER_106_380 VGND VGND VPWR VPWR sky130_fd_sc_hd__decap_3
XFILLER_69_60 VGND VGND VPWR VPWR sky130_fd_sc_hd__decap_3
XFILLER_79_231 VGND VGND VPWR VPWR sky130_fd_sc_hd__decap_3
XFILLER_79_264 VGND VGND VPWR VPWR sky130_fd_sc_hd__fill_2
XFILLER_0_691 VGND VGND VPWR VPWR sky130_fd_sc_hd__decap_3
XFILLER_67_426 VGND VGND VPWR VPWR sky130_fd_sc_hd__decap_3
XFILLER_48_651 VGND VGND VPWR VPWR sky130_fd_sc_hd__decap_3
XFILLER_94_256 VGND VGND VPWR VPWR sky130_fd_sc_hd__decap_3
XFILLER_94_278 VGND VGND VPWR VPWR sky130_fd_sc_hd__decap_3
XFILLER_35_312 VGND VGND VPWR VPWR sky130_fd_sc_hd__decap_3
XFILLER_47_172 VGND VGND VPWR VPWR sky130_fd_sc_hd__decap_3
XFILLER_48_684 VGND VGND VPWR VPWR sky130_fd_sc_hd__decap_3
XFILLER_63_632 VGND VGND VPWR VPWR sky130_fd_sc_hd__decap_3
XFILLER_85_81 VGND VGND VPWR VPWR sky130_fd_sc_hd__decap_3
XTAP_TAPCELL_ROW_89_1371 VGND VPWR sky130_fd_sc_hd__tapvpwrvgnd_1
XFILLER_35_334 VGND VGND VPWR VPWR sky130_fd_sc_hd__fill_2
XFILLER_62_120 VGND VGND VPWR VPWR sky130_fd_sc_hd__decap_3
XFILLER_63_665 VGND VGND VPWR VPWR sky130_fd_sc_hd__decap_3
XTAP_TAPCELL_ROW_46_830 VGND VPWR sky130_fd_sc_hd__tapvpwrvgnd_1
XFILLER_50_315 VGND VGND VPWR VPWR sky130_fd_sc_hd__fill_2
XFILLER_62_153 VGND VGND VPWR VPWR sky130_fd_sc_hd__fill_1
XFILLER_62_164 VGND VGND VPWR VPWR sky130_fd_sc_hd__decap_3
XFILLER_63_676 VGND VGND VPWR VPWR sky130_fd_sc_hd__decap_3
XFILLER_90_473 VGND VGND VPWR VPWR sky130_fd_sc_hd__decap_3
X_6760_ clkload8/A _6760_/D VGND VGND VPWR VPWR _6760_/Q sky130_fd_sc_hd__dfxtp_2
XFILLER_16_581 VGND VGND VPWR VPWR sky130_fd_sc_hd__decap_3
XFILLER_16_592 VGND VGND VPWR VPWR sky130_fd_sc_hd__decap_3
XFILLER_62_186 VGND VGND VPWR VPWR sky130_fd_sc_hd__decap_3
XFILLER_62_197 VGND VGND VPWR VPWR sky130_fd_sc_hd__fill_2
X_6691_ _7350_/CLK _6691_/D VGND VGND VPWR VPWR _6691_/Q sky130_fd_sc_hd__dfxtp_2
XFILLER_31_595 VGND VGND VPWR VPWR sky130_fd_sc_hd__decap_3
X_5642_ _5642_/A _5642_/B VGND VGND VPWR VPWR _5643_/A sky130_fd_sc_hd__or2_2
XFILLER_117_612 VGND VGND VPWR VPWR sky130_fd_sc_hd__decap_3
X_5573_ _5573_/A1 _5579_/S _4975_/Y VGND VGND VPWR VPWR _7044_/D sky130_fd_sc_hd__o21a_2
XFILLER_116_100 VGND VGND VPWR VPWR sky130_fd_sc_hd__decap_3
XFILLER_117_623 VGND VGND VPWR VPWR sky130_fd_sc_hd__decap_3
X_7312_ _7344_/CLK _7312_/D _6592_/Y VGND VGND VPWR VPWR _7312_/Q sky130_fd_sc_hd__dfrtp_2
X_4524_ _4524_/A0 _7285_/Q _4528_/B VGND VGND VPWR VPWR _7317_/D sky130_fd_sc_hd__mux2_2
XFILLER_116_133 VGND VGND VPWR VPWR sky130_fd_sc_hd__decap_3
XFILLER_116_144 VGND VGND VPWR VPWR sky130_fd_sc_hd__decap_3
XFILLER_117_656 VGND VGND VPWR VPWR sky130_fd_sc_hd__decap_3
XFILLER_7_290 VGND VGND VPWR VPWR sky130_fd_sc_hd__decap_3
XFILLER_116_177 VGND VGND VPWR VPWR sky130_fd_sc_hd__decap_3
X_7243_ _7371_/CLK _7243_/D _6523_/Y VGND VGND VPWR VPWR _7243_/Q sky130_fd_sc_hd__dfrtp_2
X_4455_ _4745_/A _4081_/X _4082_/X _4454_/X VGND VGND VPWR VPWR _4720_/B sky130_fd_sc_hd__o211a_2
XFILLER_104_339 VGND VGND VPWR VPWR sky130_fd_sc_hd__decap_3
XFILLER_98_551 VGND VGND VPWR VPWR sky130_fd_sc_hd__decap_3
X_7174_ _7400_/CLK _7174_/D _6454_/Y VGND VGND VPWR VPWR _7174_/Q sky130_fd_sc_hd__dfrtp_2
X_4386_ _7305_/Q _4488_/S _4437_/B1 _7369_/Q _4429_/C1 VGND VGND VPWR VPWR _4386_/X
+ sky130_fd_sc_hd__a221o_2
X_3406_ _3409_/D VGND VGND VPWR VPWR _3417_/C sky130_fd_sc_hd__inv_4
XFILLER_112_361 VGND VGND VPWR VPWR sky130_fd_sc_hd__decap_3
XFILLER_85_201 VGND VGND VPWR VPWR sky130_fd_sc_hd__decap_3
XFILLER_86_713 VGND VGND VPWR VPWR sky130_fd_sc_hd__fill_1
XFILLER_112_394 VGND VGND VPWR VPWR sky130_fd_sc_hd__decap_3
XFILLER_85_234 VGND VGND VPWR VPWR sky130_fd_sc_hd__decap_3
XFILLER_100_567 VGND VGND VPWR VPWR sky130_fd_sc_hd__decap_3
XFILLER_39_662 VGND VGND VPWR VPWR sky130_fd_sc_hd__decap_3
XFILLER_100_589 VGND VGND VPWR VPWR sky130_fd_sc_hd__fill_1
XFILLER_26_312 VGND VGND VPWR VPWR sky130_fd_sc_hd__decap_3
XFILLER_38_150 VGND VGND VPWR VPWR sky130_fd_sc_hd__decap_3
XFILLER_38_161 VGND VGND VPWR VPWR sky130_fd_sc_hd__decap_3
XFILLER_39_673 VGND VGND VPWR VPWR sky130_fd_sc_hd__decap_3
XFILLER_54_621 VGND VGND VPWR VPWR sky130_fd_sc_hd__decap_3
XFILLER_73_429 VGND VGND VPWR VPWR sky130_fd_sc_hd__decap_3
X_5007_ _5002_/Y _5003_/X _5004_/X _5005_/Y _5006_/X VGND VGND VPWR VPWR _5662_/A
+ sky130_fd_sc_hd__a221o_2
XFILLER_26_323 VGND VGND VPWR VPWR sky130_fd_sc_hd__decap_3
XFILLER_38_194 VGND VGND VPWR VPWR sky130_fd_sc_hd__fill_2
XFILLER_54_654 VGND VGND VPWR VPWR sky130_fd_sc_hd__decap_3
XFILLER_14_518 VGND VGND VPWR VPWR sky130_fd_sc_hd__decap_3
XFILLER_53_164 VGND VGND VPWR VPWR sky130_fd_sc_hd__decap_3
XFILLER_54_687 VGND VGND VPWR VPWR sky130_fd_sc_hd__decap_3
XFILLER_41_326 VGND VGND VPWR VPWR sky130_fd_sc_hd__decap_3
XFILLER_53_197 VGND VGND VPWR VPWR sky130_fd_sc_hd__decap_3
X_6958_ _6983_/CLK _6958_/D VGND VGND VPWR VPWR _6958_/Q sky130_fd_sc_hd__dfxtp_2
X_6889_ _6943_/CLK _6889_/D VGND VGND VPWR VPWR _6889_/Q sky130_fd_sc_hd__dfxtp_2
XTAP_TAPCELL_ROW_62_1032 VGND VPWR sky130_fd_sc_hd__tapvpwrvgnd_1
XTAP_TAPCELL_ROW_24_557 VGND VPWR sky130_fd_sc_hd__tapvpwrvgnd_1
XFILLER_10_713 VGND VGND VPWR VPWR sky130_fd_sc_hd__fill_1
XFILLER_22_595 VGND VGND VPWR VPWR sky130_fd_sc_hd__decap_3
XPHY_EDGE_ROW_101_Left_221 VGND VGND VPWR VPWR sky130_fd_sc_hd__decap_3
XFILLER_108_601 VGND VGND VPWR VPWR sky130_fd_sc_hd__decap_3
XFILLER_14_88 VGND VGND VPWR VPWR sky130_fd_sc_hd__fill_1
XFILLER_108_634 VGND VGND VPWR VPWR sky130_fd_sc_hd__decap_3
XFILLER_108_645 VGND VGND VPWR VPWR sky130_fd_sc_hd__decap_3
XFILLER_107_122 VGND VGND VPWR VPWR sky130_fd_sc_hd__decap_3
XFILLER_107_155 VGND VGND VPWR VPWR sky130_fd_sc_hd__decap_3
XFILLER_108_678 VGND VGND VPWR VPWR sky130_fd_sc_hd__decap_3
XFILLER_30_54 VGND VGND VPWR VPWR sky130_fd_sc_hd__decap_3
XFILLER_100_3 VGND VGND VPWR VPWR sky130_fd_sc_hd__fill_1
XFILLER_1_400 VGND VGND VPWR VPWR sky130_fd_sc_hd__decap_3
Xhold780 _6879_/Q VGND VGND VPWR VPWR _6879_/D sky130_fd_sc_hd__dlygate4sd3_1
Xhold791 _6811_/Q VGND VGND VPWR VPWR _6811_/D sky130_fd_sc_hd__dlygate4sd3_1
XFILLER_110_309 VGND VGND VPWR VPWR sky130_fd_sc_hd__decap_3
XFILLER_1_466 VGND VGND VPWR VPWR sky130_fd_sc_hd__decap_3
XFILLER_49_404 VGND VGND VPWR VPWR sky130_fd_sc_hd__decap_3
XTAP_TAPCELL_ROW_73_1172 VGND VPWR sky130_fd_sc_hd__tapvpwrvgnd_1
XFILLER_1_499 VGND VGND VPWR VPWR sky130_fd_sc_hd__decap_3
XFILLER_76_234 VGND VGND VPWR VPWR sky130_fd_sc_hd__decap_3
XPHY_EDGE_ROW_110_Left_230 VGND VGND VPWR VPWR sky130_fd_sc_hd__decap_3
XFILLER_76_289 VGND VGND VPWR VPWR sky130_fd_sc_hd__decap_3
XFILLER_17_323 VGND VGND VPWR VPWR sky130_fd_sc_hd__decap_3
XFILLER_45_632 VGND VGND VPWR VPWR sky130_fd_sc_hd__decap_3
XFILLER_57_492 VGND VGND VPWR VPWR sky130_fd_sc_hd__decap_3
XFILLER_91_248 VGND VGND VPWR VPWR sky130_fd_sc_hd__decap_3
XFILLER_17_356 VGND VGND VPWR VPWR sky130_fd_sc_hd__decap_3
XFILLER_45_665 VGND VGND VPWR VPWR sky130_fd_sc_hd__decap_3
XFILLER_45_676 VGND VGND VPWR VPWR sky130_fd_sc_hd__decap_3
XFILLER_60_613 VGND VGND VPWR VPWR sky130_fd_sc_hd__decap_3
XTAP_TAPCELL_ROW_43_800 VGND VPWR sky130_fd_sc_hd__tapvpwrvgnd_1
XFILLER_32_315 VGND VGND VPWR VPWR sky130_fd_sc_hd__decap_3
XFILLER_32_326 VGND VGND VPWR VPWR sky130_fd_sc_hd__decap_3
XFILLER_44_175 VGND VGND VPWR VPWR sky130_fd_sc_hd__decap_3
XFILLER_44_197 VGND VGND VPWR VPWR sky130_fd_sc_hd__decap_3
XFILLER_60_657 VGND VGND VPWR VPWR sky130_fd_sc_hd__decap_3
XFILLER_72_495 VGND VGND VPWR VPWR sky130_fd_sc_hd__fill_2
XFILLER_13_573 VGND VGND VPWR VPWR sky130_fd_sc_hd__decap_3
XFILLER_9_588 VGND VGND VPWR VPWR sky130_fd_sc_hd__decap_3
XFILLER_114_604 VGND VGND VPWR VPWR sky130_fd_sc_hd__decap_3
XFILLER_114_637 VGND VGND VPWR VPWR sky130_fd_sc_hd__decap_3
XFILLER_113_125 VGND VGND VPWR VPWR sky130_fd_sc_hd__decap_3
XFILLER_113_147 VGND VGND VPWR VPWR sky130_fd_sc_hd__decap_3
XFILLER_114_648 VGND VGND VPWR VPWR sky130_fd_sc_hd__decap_3
XFILLER_4_271 VGND VGND VPWR VPWR sky130_fd_sc_hd__decap_3
X_4240_ _4628_/A _4629_/B VGND VGND VPWR VPWR _4241_/B sky130_fd_sc_hd__and2_2
XFILLER_99_348 VGND VGND VPWR VPWR sky130_fd_sc_hd__decap_3
XFILLER_99_337 VGND VGND VPWR VPWR sky130_fd_sc_hd__decap_3
XFILLER_113_169 VGND VGND VPWR VPWR sky130_fd_sc_hd__fill_2
XFILLER_68_713 VGND VGND VPWR VPWR sky130_fd_sc_hd__fill_1
X_4171_ _4203_/A _4203_/B _4202_/A VGND VGND VPWR VPWR _4379_/B sky130_fd_sc_hd__a21oi_2
XFILLER_67_201 VGND VGND VPWR VPWR sky130_fd_sc_hd__decap_3
XFILLER_95_543 VGND VGND VPWR VPWR sky130_fd_sc_hd__fill_1
XFILLER_96_80 VGND VGND VPWR VPWR sky130_fd_sc_hd__decap_3
XFILLER_95_554 VGND VGND VPWR VPWR sky130_fd_sc_hd__fill_2
XFILLER_95_576 VGND VGND VPWR VPWR sky130_fd_sc_hd__decap_3
XFILLER_36_610 VGND VGND VPWR VPWR sky130_fd_sc_hd__decap_3
XFILLER_55_429 VGND VGND VPWR VPWR sky130_fd_sc_hd__decap_3
XFILLER_36_643 VGND VGND VPWR VPWR sky130_fd_sc_hd__fill_1
XFILLER_36_654 VGND VGND VPWR VPWR sky130_fd_sc_hd__decap_3
XFILLER_82_259 VGND VGND VPWR VPWR sky130_fd_sc_hd__decap_3
XFILLER_35_142 VGND VGND VPWR VPWR sky130_fd_sc_hd__decap_3
XFILLER_36_687 VGND VGND VPWR VPWR sky130_fd_sc_hd__decap_3
Xplace440 _5211_/B VGND VGND VPWR VPWR _5225_/B sky130_fd_sc_hd__buf_2
X_6812_ clkload5/A _6812_/D VGND VGND VPWR VPWR _6812_/Q sky130_fd_sc_hd__dfxtp_2
XFILLER_23_315 VGND VGND VPWR VPWR sky130_fd_sc_hd__decap_3
XFILLER_23_337 VGND VGND VPWR VPWR sky130_fd_sc_hd__decap_3
XFILLER_51_635 VGND VGND VPWR VPWR sky130_fd_sc_hd__decap_3
XFILLER_90_292 VGND VGND VPWR VPWR sky130_fd_sc_hd__decap_3
Xplace473 _3947_/S VGND VGND VPWR VPWR _3945_/S sky130_fd_sc_hd__buf_2
Xplace462 _4285_/A2 VGND VGND VPWR VPWR _4534_/S sky130_fd_sc_hd__buf_2
Xplace451 _5294_/Y VGND VGND VPWR VPWR _7412_/A sky130_fd_sc_hd__buf_2
XFILLER_23_359 VGND VGND VPWR VPWR sky130_fd_sc_hd__fill_1
XFILLER_51_668 VGND VGND VPWR VPWR sky130_fd_sc_hd__decap_3
XFILLER_51_679 VGND VGND VPWR VPWR sky130_fd_sc_hd__decap_3
Xplace495 _5602_/B VGND VGND VPWR VPWR _5634_/B sky130_fd_sc_hd__buf_2
Xplace484 _3368_/Y VGND VGND VPWR VPWR _3394_/A sky130_fd_sc_hd__buf_2
X_6743_ clkload9/A _6743_/D VGND VGND VPWR VPWR _6743_/Q sky130_fd_sc_hd__dfxtp_2
X_6674_ _6677_/A VGND VGND VPWR VPWR _6674_/Y sky130_fd_sc_hd__inv_2
XTAP_TAPCELL_ROW_21_516 VGND VPWR sky130_fd_sc_hd__tapvpwrvgnd_1
XFILLER_31_381 VGND VGND VPWR VPWR sky130_fd_sc_hd__decap_3
X_3886_ _6920_/Q _3886_/A2 _3886_/B1 _6784_/Q VGND VGND VPWR VPWR _3886_/X sky130_fd_sc_hd__a22o_2
XFILLER_117_431 VGND VGND VPWR VPWR sky130_fd_sc_hd__decap_3
XFILLER_3_709 VGND VGND VPWR VPWR sky130_fd_sc_hd__decap_3
XFILLER_105_615 VGND VGND VPWR VPWR sky130_fd_sc_hd__fill_1
XFILLER_105_626 VGND VGND VPWR VPWR sky130_fd_sc_hd__decap_3
XFILLER_117_464 VGND VGND VPWR VPWR sky130_fd_sc_hd__fill_1
X_4507_ _7326_/Q _7294_/Q _4517_/S VGND VGND VPWR VPWR _7326_/D sky130_fd_sc_hd__mux2_2
XFILLER_104_136 VGND VGND VPWR VPWR sky130_fd_sc_hd__decap_3
XFILLER_104_147 VGND VGND VPWR VPWR sky130_fd_sc_hd__decap_3
XFILLER_105_659 VGND VGND VPWR VPWR sky130_fd_sc_hd__decap_3
XFILLER_116_24 VGND VGND VPWR VPWR sky130_fd_sc_hd__decap_3
X_7226_ _7354_/CLK _7226_/D _6506_/Y VGND VGND VPWR VPWR _7226_/Q sky130_fd_sc_hd__dfrtp_2
X_4438_ _4434_/X _4437_/X _4425_/A VGND VGND VPWR VPWR _4650_/B sky130_fd_sc_hd__o21a_2
XFILLER_116_35 VGND VGND VPWR VPWR sky130_fd_sc_hd__decap_3
XFILLER_116_68 VGND VGND VPWR VPWR sky130_fd_sc_hd__decap_3
XFILLER_58_212 VGND VGND VPWR VPWR sky130_fd_sc_hd__decap_3
XFILLER_86_521 VGND VGND VPWR VPWR sky130_fd_sc_hd__decap_3
X_7157_ _7345_/CLK _7157_/D _6437_/Y VGND VGND VPWR VPWR _7157_/Q sky130_fd_sc_hd__dfrtp_2
X_4369_ _4369_/A _4369_/B VGND VGND VPWR VPWR _4369_/Y sky130_fd_sc_hd__nor2_2
XFILLER_112_180 VGND VGND VPWR VPWR sky130_fd_sc_hd__decap_3
XFILLER_46_407 VGND VGND VPWR VPWR sky130_fd_sc_hd__decap_3
XFILLER_58_245 VGND VGND VPWR VPWR sky130_fd_sc_hd__decap_3
X_7088_ _7355_/CLK _7088_/D _6368_/Y VGND VGND VPWR VPWR _7088_/Q sky130_fd_sc_hd__dfrtp_2
XFILLER_100_375 VGND VGND VPWR VPWR sky130_fd_sc_hd__decap_3
XFILLER_18_109 VGND VGND VPWR VPWR sky130_fd_sc_hd__decap_3
XFILLER_39_470 VGND VGND VPWR VPWR sky130_fd_sc_hd__decap_3
XFILLER_46_429 VGND VGND VPWR VPWR sky130_fd_sc_hd__decap_3
XFILLER_58_278 VGND VGND VPWR VPWR sky130_fd_sc_hd__decap_3
XFILLER_73_204 VGND VGND VPWR VPWR sky130_fd_sc_hd__decap_3
XTAP_TAPCELL_ROW_29_616 VGND VPWR sky130_fd_sc_hd__tapvpwrvgnd_1
XFILLER_27_632 VGND VGND VPWR VPWR sky130_fd_sc_hd__decap_3
XFILLER_73_237 VGND VGND VPWR VPWR sky130_fd_sc_hd__fill_1
XFILLER_73_259 VGND VGND VPWR VPWR sky130_fd_sc_hd__decap_3
XFILLER_92_27 VGND VGND VPWR VPWR sky130_fd_sc_hd__fill_1
XTAP_TAPCELL_ROW_57_969 VGND VPWR sky130_fd_sc_hd__tapvpwrvgnd_1
XFILLER_27_665 VGND VGND VPWR VPWR sky130_fd_sc_hd__decap_3
XFILLER_27_676 VGND VGND VPWR VPWR sky130_fd_sc_hd__decap_3
XFILLER_54_451 VGND VGND VPWR VPWR sky130_fd_sc_hd__decap_3
XFILLER_54_473 VGND VGND VPWR VPWR sky130_fd_sc_hd__decap_3
XFILLER_92_38 VGND VGND VPWR VPWR sky130_fd_sc_hd__fill_2
XTAP_TAPCELL_ROW_1_274 VGND VPWR sky130_fd_sc_hd__tapvpwrvgnd_1
XFILLER_14_315 VGND VGND VPWR VPWR sky130_fd_sc_hd__decap_3
XFILLER_26_197 VGND VGND VPWR VPWR sky130_fd_sc_hd__decap_3
XFILLER_42_624 VGND VGND VPWR VPWR sky130_fd_sc_hd__decap_3
XTAP_TAPCELL_ROW_107_1599 VGND VPWR sky130_fd_sc_hd__tapvpwrvgnd_1
XFILLER_25_87 VGND VGND VPWR VPWR sky130_fd_sc_hd__decap_3
XFILLER_42_657 VGND VGND VPWR VPWR sky130_fd_sc_hd__decap_3
XFILLER_50_690 VGND VGND VPWR VPWR sky130_fd_sc_hd__decap_3
XFILLER_10_554 VGND VGND VPWR VPWR sky130_fd_sc_hd__decap_3
XFILLER_10_587 VGND VGND VPWR VPWR sky130_fd_sc_hd__fill_1
XFILLER_6_536 VGND VGND VPWR VPWR sky130_fd_sc_hd__decap_3
XFILLER_10_598 VGND VGND VPWR VPWR sky130_fd_sc_hd__decap_3
XFILLER_6_569 VGND VGND VPWR VPWR sky130_fd_sc_hd__decap_3
XTAP_TAPCELL_ROW_75_1201 VGND VPWR sky130_fd_sc_hd__tapvpwrvgnd_1
XFILLER_108_475 VGND VGND VPWR VPWR sky130_fd_sc_hd__fill_1
XFILLER_108_486 VGND VGND VPWR VPWR sky130_fd_sc_hd__fill_2
XFILLER_111_629 VGND VGND VPWR VPWR sky130_fd_sc_hd__decap_3
XFILLER_1_252 VGND VGND VPWR VPWR sky130_fd_sc_hd__decap_3
XTAP_TAPCELL_ROW_9_374 VGND VPWR sky130_fd_sc_hd__tapvpwrvgnd_1
XFILLER_104_681 VGND VGND VPWR VPWR sky130_fd_sc_hd__decap_3
XFILLER_110_106 VGND VGND VPWR VPWR sky130_fd_sc_hd__decap_3
XFILLER_110_139 VGND VGND VPWR VPWR sky130_fd_sc_hd__fill_1
XFILLER_1_274 VGND VGND VPWR VPWR sky130_fd_sc_hd__fill_1
XFILLER_49_201 VGND VGND VPWR VPWR sky130_fd_sc_hd__decap_3
XFILLER_49_234 VGND VGND VPWR VPWR sky130_fd_sc_hd__decap_3
XFILLER_77_554 VGND VGND VPWR VPWR sky130_fd_sc_hd__decap_3
XFILLER_18_610 VGND VGND VPWR VPWR sky130_fd_sc_hd__decap_3
XFILLER_49_278 VGND VGND VPWR VPWR sky130_fd_sc_hd__fill_2
XFILLER_66_61 VGND VGND VPWR VPWR sky130_fd_sc_hd__decap_3
XFILLER_92_513 VGND VGND VPWR VPWR sky130_fd_sc_hd__decap_3
XFILLER_92_524 VGND VGND VPWR VPWR sky130_fd_sc_hd__decap_3
XFILLER_18_643 VGND VGND VPWR VPWR sky130_fd_sc_hd__fill_1
XFILLER_18_654 VGND VGND VPWR VPWR sky130_fd_sc_hd__decap_3
XFILLER_66_94 VGND VGND VPWR VPWR sky130_fd_sc_hd__decap_3
XFILLER_92_568 VGND VGND VPWR VPWR sky130_fd_sc_hd__fill_1
XTAP_TAPCELL_ROW_86_1330 VGND VPWR sky130_fd_sc_hd__tapvpwrvgnd_1
XFILLER_18_687 VGND VGND VPWR VPWR sky130_fd_sc_hd__decap_3
XFILLER_33_635 VGND VGND VPWR VPWR sky130_fd_sc_hd__decap_3
XFILLER_45_484 VGND VGND VPWR VPWR sky130_fd_sc_hd__decap_3
XFILLER_60_432 VGND VGND VPWR VPWR sky130_fd_sc_hd__decap_3
XFILLER_72_270 VGND VGND VPWR VPWR sky130_fd_sc_hd__decap_3
XFILLER_32_134 VGND VGND VPWR VPWR sky130_fd_sc_hd__decap_3
XFILLER_33_668 VGND VGND VPWR VPWR sky130_fd_sc_hd__decap_3
XFILLER_33_679 VGND VGND VPWR VPWR sky130_fd_sc_hd__decap_3
XFILLER_60_465 VGND VGND VPWR VPWR sky130_fd_sc_hd__fill_2
XFILLER_82_82 VGND VGND VPWR VPWR sky130_fd_sc_hd__fill_2
XFILLER_13_370 VGND VGND VPWR VPWR sky130_fd_sc_hd__decap_3
XFILLER_20_318 VGND VGND VPWR VPWR sky130_fd_sc_hd__decap_3
XFILLER_32_178 VGND VGND VPWR VPWR sky130_fd_sc_hd__fill_2
X_3740_ _6710_/Q _5660_/B _3925_/B1 _6888_/Q _3739_/X VGND VGND VPWR VPWR _3740_/X
+ sky130_fd_sc_hd__a221o_2
X_3671_ _3671_/A1 _4832_/A _3670_/X VGND VGND VPWR VPWR _7405_/D sky130_fd_sc_hd__o21a_2
XFILLER_9_374 VGND VGND VPWR VPWR sky130_fd_sc_hd__decap_3
XFILLER_9_363 VGND VGND VPWR VPWR sky130_fd_sc_hd__fill_1
X_6390_ _6584_/A VGND VGND VPWR VPWR _6390_/Y sky130_fd_sc_hd__inv_2
XFILLER_9_396 VGND VGND VPWR VPWR sky130_fd_sc_hd__decap_3
XTAP_TAPCELL_ROW_97_1470 VGND VPWR sky130_fd_sc_hd__tapvpwrvgnd_1
XFILLER_114_434 VGND VGND VPWR VPWR sky130_fd_sc_hd__decap_3
XFILLER_5_591 VGND VGND VPWR VPWR sky130_fd_sc_hd__decap_3
XFILLER_99_134 VGND VGND VPWR VPWR sky130_fd_sc_hd__decap_3
X_7011_ _7354_/CLK _7011_/D _6291_/Y VGND VGND VPWR VPWR _7011_/Q sky130_fd_sc_hd__dfrtp_2
X_5272_ _5272_/A0 _5061_/X _5272_/S VGND VGND VPWR VPWR _7194_/D sky130_fd_sc_hd__mux2_2
XFILLER_99_145 VGND VGND VPWR VPWR sky130_fd_sc_hd__decap_3
XFILLER_68_521 VGND VGND VPWR VPWR sky130_fd_sc_hd__decap_3
X_4223_ _4217_/X _4219_/X _4222_/X _4327_/A VGND VGND VPWR VPWR _4224_/C sky130_fd_sc_hd__o31a_2
XFILLER_110_640 VGND VGND VPWR VPWR sky130_fd_sc_hd__decap_3
XFILLER_110_651 VGND VGND VPWR VPWR sky130_fd_sc_hd__decap_3
XFILLER_95_340 VGND VGND VPWR VPWR sky130_fd_sc_hd__decap_3
X_4154_ _7047_/Q _4269_/B1 _4437_/B1 _7394_/Q _4153_/X VGND VGND VPWR VPWR _4154_/X
+ sky130_fd_sc_hd__a221o_2
XFILLER_110_684 VGND VGND VPWR VPWR sky130_fd_sc_hd__decap_3
XFILLER_28_407 VGND VGND VPWR VPWR sky130_fd_sc_hd__decap_3
XFILLER_55_215 VGND VGND VPWR VPWR sky130_fd_sc_hd__decap_3
XFILLER_95_362 VGND VGND VPWR VPWR sky130_fd_sc_hd__decap_3
X_4085_ _7238_/Q _4430_/A2 _4428_/B1 _7142_/Q _4084_/X VGND VGND VPWR VPWR _4085_/X
+ sky130_fd_sc_hd__a221o_2
XFILLER_55_237 VGND VGND VPWR VPWR sky130_fd_sc_hd__decap_3
XFILLER_36_451 VGND VGND VPWR VPWR sky130_fd_sc_hd__decap_3
XFILLER_70_218 VGND VGND VPWR VPWR sky130_fd_sc_hd__decap_3
XTAP_TAPCELL_ROW_54_928 VGND VPWR sky130_fd_sc_hd__tapvpwrvgnd_1
XFILLER_23_101 VGND VGND VPWR VPWR sky130_fd_sc_hd__decap_3
XFILLER_24_613 VGND VGND VPWR VPWR sky130_fd_sc_hd__decap_3
XFILLER_36_484 VGND VGND VPWR VPWR sky130_fd_sc_hd__decap_3
XTAP_TAPCELL_ROW_54_939 VGND VPWR sky130_fd_sc_hd__tapvpwrvgnd_1
XFILLER_23_134 VGND VGND VPWR VPWR sky130_fd_sc_hd__decap_3
XFILLER_24_657 VGND VGND VPWR VPWR sky130_fd_sc_hd__decap_3
XFILLER_11_307 VGND VGND VPWR VPWR sky130_fd_sc_hd__decap_3
X_6726_ clkload3/A _6726_/D VGND VGND VPWR VPWR _6726_/Q sky130_fd_sc_hd__dfxtp_2
X_4987_ _4987_/A _4987_/B VGND VGND VPWR VPWR _4987_/Y sky130_fd_sc_hd__xnor2_2
XTAP_TAPCELL_ROW_34_685 VGND VPWR sky130_fd_sc_hd__tapvpwrvgnd_1
XFILLER_32_690 VGND VGND VPWR VPWR sky130_fd_sc_hd__decap_3
XFILLER_109_228 VGND VGND VPWR VPWR sky130_fd_sc_hd__decap_3
X_6657_ _6664_/A VGND VGND VPWR VPWR _6657_/Y sky130_fd_sc_hd__inv_2
X_3869_ _6772_/Q _3921_/A2 _3912_/B1 _6766_/Q VGND VGND VPWR VPWR _3869_/X sky130_fd_sc_hd__a22o_2
X_6588_ _6621_/A VGND VGND VPWR VPWR _6588_/Y sky130_fd_sc_hd__inv_2
XFILLER_11_67 VGND VGND VPWR VPWR sky130_fd_sc_hd__fill_1
XFILLER_3_517 VGND VGND VPWR VPWR sky130_fd_sc_hd__decap_3
XFILLER_105_412 VGND VGND VPWR VPWR sky130_fd_sc_hd__fill_1
XFILLER_105_467 VGND VGND VPWR VPWR sky130_fd_sc_hd__fill_1
XFILLER_78_318 VGND VGND VPWR VPWR sky130_fd_sc_hd__decap_3
Xoutput660 _6984_/Q VGND VGND VPWR VPWR pc_out[7] sky130_fd_sc_hd__clkdlybuf4s25_1
XFILLER_105_489 VGND VGND VPWR VPWR sky130_fd_sc_hd__decap_3
X_7209_ _7402_/CLK _7209_/D _6489_/Y VGND VGND VPWR VPWR _7209_/Q sky130_fd_sc_hd__dfrtp_2
XTAP_TAPCELL_ROW_70_1131 VGND VPWR sky130_fd_sc_hd__tapvpwrvgnd_1
XTAP_TAPCELL_ROW_6_333 VGND VPWR sky130_fd_sc_hd__tapvpwrvgnd_1
XFILLER_59_532 VGND VGND VPWR VPWR sky130_fd_sc_hd__fill_1
XFILLER_59_554 VGND VGND VPWR VPWR sky130_fd_sc_hd__decap_3
XFILLER_100_150 VGND VGND VPWR VPWR sky130_fd_sc_hd__decap_3
XFILLER_101_662 VGND VGND VPWR VPWR sky130_fd_sc_hd__decap_3
XFILLER_101_673 VGND VGND VPWR VPWR sky130_fd_sc_hd__decap_3
XFILLER_59_598 VGND VGND VPWR VPWR sky130_fd_sc_hd__fill_2
XTAP_TAPCELL_ROW_109_1617 VGND VPWR sky130_fd_sc_hd__tapvpwrvgnd_1
XFILLER_46_226 VGND VGND VPWR VPWR sky130_fd_sc_hd__decap_3
XFILLER_46_248 VGND VGND VPWR VPWR sky130_fd_sc_hd__decap_3
XFILLER_15_602 VGND VGND VPWR VPWR sky130_fd_sc_hd__decap_3
XFILLER_61_207 VGND VGND VPWR VPWR sky130_fd_sc_hd__decap_3
XFILLER_14_112 VGND VGND VPWR VPWR sky130_fd_sc_hd__decap_3
XFILLER_15_635 VGND VGND VPWR VPWR sky130_fd_sc_hd__decap_3
XFILLER_27_484 VGND VGND VPWR VPWR sky130_fd_sc_hd__decap_3
XFILLER_15_668 VGND VGND VPWR VPWR sky130_fd_sc_hd__decap_3
XFILLER_15_679 VGND VGND VPWR VPWR sky130_fd_sc_hd__decap_3
XFILLER_42_432 VGND VGND VPWR VPWR sky130_fd_sc_hd__decap_3
XFILLER_14_178 VGND VGND VPWR VPWR sky130_fd_sc_hd__decap_3
XFILLER_30_616 VGND VGND VPWR VPWR sky130_fd_sc_hd__decap_3
XFILLER_52_85 VGND VGND VPWR VPWR sky130_fd_sc_hd__decap_3
XTAP_TAPCELL_ROW_81_1271 VGND VPWR sky130_fd_sc_hd__tapvpwrvgnd_1
XFILLER_10_340 VGND VGND VPWR VPWR sky130_fd_sc_hd__decap_3
XFILLER_6_333 VGND VGND VPWR VPWR sky130_fd_sc_hd__decap_3
XFILLER_111_404 VGND VGND VPWR VPWR sky130_fd_sc_hd__fill_2
XFILLER_2_572 VGND VGND VPWR VPWR sky130_fd_sc_hd__decap_3
XFILLER_97_638 VGND VGND VPWR VPWR sky130_fd_sc_hd__decap_3
XFILLER_77_340 VGND VGND VPWR VPWR sky130_fd_sc_hd__decap_3
XFILLER_77_60 VGND VGND VPWR VPWR sky130_fd_sc_hd__decap_3
XFILLER_77_82 VGND VGND VPWR VPWR sky130_fd_sc_hd__decap_3
XFILLER_96_137 VGND VGND VPWR VPWR sky130_fd_sc_hd__decap_3
XFILLER_96_159 VGND VGND VPWR VPWR sky130_fd_sc_hd__decap_3
XFILLER_37_215 VGND VGND VPWR VPWR sky130_fd_sc_hd__decap_3
XFILLER_77_373 VGND VGND VPWR VPWR sky130_fd_sc_hd__fill_1
XFILLER_37_248 VGND VGND VPWR VPWR sky130_fd_sc_hd__decap_3
XFILLER_92_321 VGND VGND VPWR VPWR sky130_fd_sc_hd__decap_3
XFILLER_92_332 VGND VGND VPWR VPWR sky130_fd_sc_hd__decap_3
XFILLER_18_462 VGND VGND VPWR VPWR sky130_fd_sc_hd__decap_3
XFILLER_92_354 VGND VGND VPWR VPWR sky130_fd_sc_hd__fill_1
XFILLER_92_365 VGND VGND VPWR VPWR sky130_fd_sc_hd__decap_3
XFILLER_92_376 VGND VGND VPWR VPWR sky130_fd_sc_hd__decap_3
XFILLER_45_281 VGND VGND VPWR VPWR sky130_fd_sc_hd__fill_2
XFILLER_52_218 VGND VGND VPWR VPWR sky130_fd_sc_hd__decap_3
XFILLER_93_81 VGND VGND VPWR VPWR sky130_fd_sc_hd__fill_1
X_4910_ _4910_/A _4910_/B VGND VGND VPWR VPWR _4910_/Y sky130_fd_sc_hd__nand2_2
X_4841_ _4890_/B _4888_/B VGND VGND VPWR VPWR _4841_/Y sky130_fd_sc_hd__nand2b_2
XFILLER_21_638 VGND VGND VPWR VPWR sky130_fd_sc_hd__decap_3
XFILLER_14_690 VGND VGND VPWR VPWR sky130_fd_sc_hd__decap_3
XFILLER_33_498 VGND VGND VPWR VPWR sky130_fd_sc_hd__decap_3
X_4772_ _4772_/A0 _4771_/X _4865_/S VGND VGND VPWR VPWR _7275_/D sky130_fd_sc_hd__mux2_2
XTAP_TAPCELL_ROW_31_644 VGND VPWR sky130_fd_sc_hd__tapvpwrvgnd_1
X_6511_ _6610_/A VGND VGND VPWR VPWR _6511_/Y sky130_fd_sc_hd__inv_2
X_3723_ _6813_/Q _3893_/B1 _3883_/B1 _6823_/Q VGND VGND VPWR VPWR _3723_/X sky130_fd_sc_hd__a22o_2
X_6442_ _6636_/A VGND VGND VPWR VPWR _6442_/Y sky130_fd_sc_hd__inv_2
XTAP_TAPCELL_ROW_11_390 VGND VPWR sky130_fd_sc_hd__tapvpwrvgnd_1
X_6373_ _6598_/A VGND VGND VPWR VPWR _6373_/Y sky130_fd_sc_hd__inv_2
X_3585_ _3591_/A _3591_/B _3591_/C _3586_/D VGND VGND VPWR VPWR _3599_/A sky130_fd_sc_hd__o31a_2
XFILLER_88_605 VGND VGND VPWR VPWR sky130_fd_sc_hd__decap_3
XFILLER_102_415 VGND VGND VPWR VPWR sky130_fd_sc_hd__decap_3
XFILLER_114_264 VGND VGND VPWR VPWR sky130_fd_sc_hd__decap_3
XFILLER_88_627 VGND VGND VPWR VPWR sky130_fd_sc_hd__decap_3
XFILLER_87_137 VGND VGND VPWR VPWR sky130_fd_sc_hd__decap_3
XFILLER_87_159 VGND VGND VPWR VPWR sky130_fd_sc_hd__decap_3
X_4206_ _4920_/A _4204_/Y _4205_/X VGND VGND VPWR VPWR _4206_/X sky130_fd_sc_hd__a21o_2
XFILLER_96_660 VGND VGND VPWR VPWR sky130_fd_sc_hd__decap_3
X_5186_ _5186_/A _5207_/B VGND VGND VPWR VPWR _7235_/D sky130_fd_sc_hd__and2_2
XFILLER_28_215 VGND VGND VPWR VPWR sky130_fd_sc_hd__decap_3
XFILLER_83_321 VGND VGND VPWR VPWR sky130_fd_sc_hd__fill_2
XFILLER_95_181 VGND VGND VPWR VPWR sky130_fd_sc_hd__decap_3
XFILLER_96_693 VGND VGND VPWR VPWR sky130_fd_sc_hd__decap_3
X_4137_ _7048_/Q _4269_/B1 _4437_/B1 _7395_/Q _4136_/X VGND VGND VPWR VPWR _4137_/X
+ sky130_fd_sc_hd__a221o_2
XTAP_TAPCELL_ROW_39_744 VGND VPWR sky130_fd_sc_hd__tapvpwrvgnd_1
XFILLER_113_47 VGND VGND VPWR VPWR sky130_fd_sc_hd__decap_3
XFILLER_113_69 VGND VGND VPWR VPWR sky130_fd_sc_hd__decap_3
XFILLER_71_505 VGND VGND VPWR VPWR sky130_fd_sc_hd__decap_3
X_4068_ _4068_/A _4082_/A VGND VGND VPWR VPWR _4069_/B sky130_fd_sc_hd__nor2_2
XFILLER_71_538 VGND VGND VPWR VPWR sky130_fd_sc_hd__decap_3
XFILLER_24_432 VGND VGND VPWR VPWR sky130_fd_sc_hd__decap_3
XFILLER_51_240 VGND VGND VPWR VPWR sky130_fd_sc_hd__decap_3
XTAP_TAPCELL_ROW_19_490 VGND VPWR sky130_fd_sc_hd__tapvpwrvgnd_1
XTAP_TAPCELL_ROW_104_1558 VGND VPWR sky130_fd_sc_hd__tapvpwrvgnd_1
XFILLER_12_616 VGND VGND VPWR VPWR sky130_fd_sc_hd__decap_3
XFILLER_24_498 VGND VGND VPWR VPWR sky130_fd_sc_hd__decap_3
XFILLER_51_284 VGND VGND VPWR VPWR sky130_fd_sc_hd__decap_3
XFILLER_20_660 VGND VGND VPWR VPWR sky130_fd_sc_hd__decap_3
X_6709_ _6943_/CLK _6709_/D VGND VGND VPWR VPWR _6709_/Q sky130_fd_sc_hd__dfxtp_2
XFILLER_20_693 VGND VGND VPWR VPWR sky130_fd_sc_hd__decap_3
XFILLER_106_710 VGND VGND VPWR VPWR sky130_fd_sc_hd__decap_3
XFILLER_22_88 VGND VGND VPWR VPWR sky130_fd_sc_hd__decap_3
XFILLER_98_26 VGND VGND VPWR VPWR sky130_fd_sc_hd__fill_2
XFILLER_118_581 VGND VGND VPWR VPWR sky130_fd_sc_hd__decap_3
XFILLER_118_592 VGND VGND VPWR VPWR sky130_fd_sc_hd__decap_3
XFILLER_3_303 VGND VGND VPWR VPWR sky130_fd_sc_hd__decap_3
XFILLER_3_325 VGND VGND VPWR VPWR sky130_fd_sc_hd__decap_3
XFILLER_105_231 VGND VGND VPWR VPWR sky130_fd_sc_hd__decap_3
XFILLER_3_358 VGND VGND VPWR VPWR sky130_fd_sc_hd__decap_3
XFILLER_78_115 VGND VGND VPWR VPWR sky130_fd_sc_hd__decap_3
XFILLER_79_638 VGND VGND VPWR VPWR sky130_fd_sc_hd__decap_3
XTAP_TAPCELL_ROW_115_1698 VGND VPWR sky130_fd_sc_hd__tapvpwrvgnd_1
XFILLER_87_682 VGND VGND VPWR VPWR sky130_fd_sc_hd__decap_3
XFILLER_94_619 VGND VGND VPWR VPWR sky130_fd_sc_hd__decap_3
XFILLER_47_52 VGND VGND VPWR VPWR sky130_fd_sc_hd__decap_3
XFILLER_19_259 VGND VGND VPWR VPWR sky130_fd_sc_hd__decap_3
XFILLER_74_365 VGND VGND VPWR VPWR sky130_fd_sc_hd__decap_3
XFILLER_27_270 VGND VGND VPWR VPWR sky130_fd_sc_hd__decap_3
XFILLER_34_229 VGND VGND VPWR VPWR sky130_fd_sc_hd__decap_3
XTAP_TAPCELL_ROW_83_1300 VGND VPWR sky130_fd_sc_hd__tapvpwrvgnd_1
XFILLER_103_91 VGND VGND VPWR VPWR sky130_fd_sc_hd__decap_3
XFILLER_15_443 VGND VGND VPWR VPWR sky130_fd_sc_hd__decap_3
XFILLER_27_281 VGND VGND VPWR VPWR sky130_fd_sc_hd__decap_3
XFILLER_15_476 VGND VGND VPWR VPWR sky130_fd_sc_hd__decap_3
XFILLER_30_413 VGND VGND VPWR VPWR sky130_fd_sc_hd__decap_3
XFILLER_42_262 VGND VGND VPWR VPWR sky130_fd_sc_hd__decap_3
XFILLER_30_424 VGND VGND VPWR VPWR sky130_fd_sc_hd__decap_3
XFILLER_42_284 VGND VGND VPWR VPWR sky130_fd_sc_hd__decap_3
XFILLER_11_671 VGND VGND VPWR VPWR sky130_fd_sc_hd__fill_1
XFILLER_11_682 VGND VGND VPWR VPWR sky130_fd_sc_hd__decap_3
XFILLER_7_620 VGND VGND VPWR VPWR sky130_fd_sc_hd__decap_3
XFILLER_116_507 VGND VGND VPWR VPWR sky130_fd_sc_hd__decap_3
XFILLER_6_141 VGND VGND VPWR VPWR sky130_fd_sc_hd__decap_3
XFILLER_7_653 VGND VGND VPWR VPWR sky130_fd_sc_hd__decap_3
XFILLER_7_697 VGND VGND VPWR VPWR sky130_fd_sc_hd__decap_3
X_3370_ _5129_/A _3561_/B VGND VGND VPWR VPWR _3370_/Y sky130_fd_sc_hd__nor2_2
XFILLER_112_713 VGND VGND VPWR VPWR sky130_fd_sc_hd__fill_1
XFILLER_88_70 VGND VGND VPWR VPWR sky130_fd_sc_hd__decap_3
XFILLER_111_234 VGND VGND VPWR VPWR sky130_fd_sc_hd__fill_2
XFILLER_97_446 VGND VGND VPWR VPWR sky130_fd_sc_hd__fill_2
XFILLER_97_468 VGND VGND VPWR VPWR sky130_fd_sc_hd__decap_3
X_5040_ _6989_/D _5039_/X _5156_/S VGND VGND VPWR VPWR _5040_/X sky130_fd_sc_hd__mux2_2
XFILLER_111_256 VGND VGND VPWR VPWR sky130_fd_sc_hd__decap_3
XFILLER_78_660 VGND VGND VPWR VPWR sky130_fd_sc_hd__decap_3
XFILLER_84_118 VGND VGND VPWR VPWR sky130_fd_sc_hd__decap_3
Xhold1309 _7124_/Q VGND VGND VPWR VPWR _5419_/A0 sky130_fd_sc_hd__dlygate4sd3_1
XFILLER_78_693 VGND VGND VPWR VPWR sky130_fd_sc_hd__decap_3
XFILLER_93_641 VGND VGND VPWR VPWR sky130_fd_sc_hd__decap_3
XFILLER_53_505 VGND VGND VPWR VPWR sky130_fd_sc_hd__decap_3
X_6991_ _7403_/CLK _6991_/D _6271_/Y VGND VGND VPWR VPWR _6991_/Q sky130_fd_sc_hd__dfrtp_2
XFILLER_53_527 VGND VGND VPWR VPWR sky130_fd_sc_hd__decap_3
XFILLER_80_324 VGND VGND VPWR VPWR sky130_fd_sc_hd__decap_3
XFILLER_92_162 VGND VGND VPWR VPWR sky130_fd_sc_hd__decap_3
XFILLER_93_685 VGND VGND VPWR VPWR sky130_fd_sc_hd__decap_3
XTAP_TAPCELL_ROW_36_714 VGND VPWR sky130_fd_sc_hd__tapvpwrvgnd_1
XTAP_TAPCELL_ROW_36_703 VGND VPWR sky130_fd_sc_hd__tapvpwrvgnd_1
XFILLER_18_281 VGND VGND VPWR VPWR sky130_fd_sc_hd__decap_3
XFILLER_80_346 VGND VGND VPWR VPWR sky130_fd_sc_hd__decap_3
XFILLER_80_368 VGND VGND VPWR VPWR sky130_fd_sc_hd__decap_3
XFILLER_33_251 VGND VGND VPWR VPWR sky130_fd_sc_hd__decap_3
XTAP_TAPCELL_ROW_16_460 VGND VPWR sky130_fd_sc_hd__tapvpwrvgnd_1
XFILLER_21_446 VGND VGND VPWR VPWR sky130_fd_sc_hd__fill_2
XFILLER_33_284 VGND VGND VPWR VPWR sky130_fd_sc_hd__decap_3
X_4755_ _7005_/Q _4775_/A VGND VGND VPWR VPWR _7005_/D sky130_fd_sc_hd__xor2_2
XFILLER_119_378 VGND VGND VPWR VPWR sky130_fd_sc_hd__decap_3
X_4686_ _6999_/Q _7000_/Q _4858_/B VGND VGND VPWR VPWR _4687_/B sky130_fd_sc_hd__and3_2
X_6425_ _6554_/A VGND VGND VPWR VPWR _6425_/Y sky130_fd_sc_hd__inv_2
X_3637_ _3636_/Y _5103_/A1 _3505_/X _3618_/X VGND VGND VPWR VPWR _3637_/X sky130_fd_sc_hd__a22o_2
XFILLER_108_47 VGND VGND VPWR VPWR sky130_fd_sc_hd__decap_3
XFILLER_115_551 VGND VGND VPWR VPWR sky130_fd_sc_hd__decap_3
X_6356_ _6683_/A VGND VGND VPWR VPWR _6356_/Y sky130_fd_sc_hd__inv_2
X_3568_ _7093_/Q _3417_/X _3407_/X _7125_/Q VGND VGND VPWR VPWR _3568_/X sky130_fd_sc_hd__a22o_2
XFILLER_0_306 VGND VGND VPWR VPWR sky130_fd_sc_hd__fill_2
XFILLER_115_584 VGND VGND VPWR VPWR sky130_fd_sc_hd__decap_3
XFILLER_68_29 VGND VGND VPWR VPWR sky130_fd_sc_hd__fill_2
XFILLER_88_413 VGND VGND VPWR VPWR sky130_fd_sc_hd__decap_3
XFILLER_88_424 VGND VGND VPWR VPWR sky130_fd_sc_hd__decap_3
X_6287_ _6288_/A VGND VGND VPWR VPWR _6287_/Y sky130_fd_sc_hd__inv_2
X_3499_ _3538_/B1 _5737_/S _3497_/X _5152_/B VGND VGND VPWR VPWR _3541_/B sky130_fd_sc_hd__a31oi_4
XFILLER_102_256 VGND VGND VPWR VPWR sky130_fd_sc_hd__decap_3
XFILLER_69_671 VGND VGND VPWR VPWR sky130_fd_sc_hd__fill_1
X_5238_ _5362_/C _5238_/B _5229_/C VGND VGND VPWR VPWR _5238_/X sky130_fd_sc_hd__or3b_2
XFILLER_102_289 VGND VGND VPWR VPWR sky130_fd_sc_hd__decap_3
XFILLER_69_682 VGND VGND VPWR VPWR sky130_fd_sc_hd__decap_3
XFILLER_75_129 VGND VGND VPWR VPWR sky130_fd_sc_hd__decap_3
XFILLER_96_490 VGND VGND VPWR VPWR sky130_fd_sc_hd__fill_2
X_5169_ _5169_/A _5198_/B VGND VGND VPWR VPWR _7243_/D sky130_fd_sc_hd__and2_2
XFILLER_29_579 VGND VGND VPWR VPWR sky130_fd_sc_hd__decap_3
XFILLER_44_505 VGND VGND VPWR VPWR sky130_fd_sc_hd__decap_3
XFILLER_56_365 VGND VGND VPWR VPWR sky130_fd_sc_hd__fill_1
XFILLER_84_663 VGND VGND VPWR VPWR sky130_fd_sc_hd__decap_3
XFILLER_44_516 VGND VGND VPWR VPWR sky130_fd_sc_hd__fill_2
XFILLER_56_376 VGND VGND VPWR VPWR sky130_fd_sc_hd__fill_1
XFILLER_56_398 VGND VGND VPWR VPWR sky130_fd_sc_hd__decap_3
XFILLER_83_184 VGND VGND VPWR VPWR sky130_fd_sc_hd__decap_3
XFILLER_84_696 VGND VGND VPWR VPWR sky130_fd_sc_hd__decap_3
XFILLER_37_590 VGND VGND VPWR VPWR sky130_fd_sc_hd__decap_3
XFILLER_12_402 VGND VGND VPWR VPWR sky130_fd_sc_hd__decap_3
XFILLER_24_251 VGND VGND VPWR VPWR sky130_fd_sc_hd__fill_1
XFILLER_24_262 VGND VGND VPWR VPWR sky130_fd_sc_hd__fill_2
XTAP_TAPCELL_ROW_65_1074 VGND VPWR sky130_fd_sc_hd__tapvpwrvgnd_1
XFILLER_12_424 VGND VGND VPWR VPWR sky130_fd_sc_hd__fill_2
XFILLER_33_43 VGND VGND VPWR VPWR sky130_fd_sc_hd__decap_3
XFILLER_33_65 VGND VGND VPWR VPWR sky130_fd_sc_hd__fill_2
XTAP_TAPCELL_ROW_117_1716 VGND VPWR sky130_fd_sc_hd__tapvpwrvgnd_1
XFILLER_4_623 VGND VGND VPWR VPWR sky130_fd_sc_hd__decap_3
XFILLER_4_645 VGND VGND VPWR VPWR sky130_fd_sc_hd__decap_3
XFILLER_106_573 VGND VGND VPWR VPWR sky130_fd_sc_hd__fill_2
XFILLER_106_584 VGND VGND VPWR VPWR sky130_fd_sc_hd__decap_3
XFILLER_4_678 VGND VGND VPWR VPWR sky130_fd_sc_hd__decap_3
XFILLER_106_595 VGND VGND VPWR VPWR sky130_fd_sc_hd__decap_3
XFILLER_58_62 VGND VGND VPWR VPWR sky130_fd_sc_hd__decap_3
XFILLER_66_107 VGND VGND VPWR VPWR sky130_fd_sc_hd__decap_3
XFILLER_79_479 VGND VGND VPWR VPWR sky130_fd_sc_hd__decap_3
XFILLER_94_427 VGND VGND VPWR VPWR sky130_fd_sc_hd__decap_3
XFILLER_47_310 VGND VGND VPWR VPWR sky130_fd_sc_hd__decap_3
XFILLER_94_449 VGND VGND VPWR VPWR sky130_fd_sc_hd__decap_3
XFILLER_35_505 VGND VGND VPWR VPWR sky130_fd_sc_hd__fill_2
XFILLER_75_641 VGND VGND VPWR VPWR sky130_fd_sc_hd__decap_3
XFILLER_74_162 VGND VGND VPWR VPWR sky130_fd_sc_hd__decap_3
XFILLER_75_685 VGND VGND VPWR VPWR sky130_fd_sc_hd__decap_3
XFILLER_90_622 VGND VGND VPWR VPWR sky130_fd_sc_hd__decap_3
XFILLER_74_195 VGND VGND VPWR VPWR sky130_fd_sc_hd__fill_1
XFILLER_74_83 VGND VGND VPWR VPWR sky130_fd_sc_hd__fill_1
XFILLER_74_94 VGND VGND VPWR VPWR sky130_fd_sc_hd__decap_3
XFILLER_90_666 VGND VGND VPWR VPWR sky130_fd_sc_hd__decap_3
XFILLER_31_700 VGND VGND VPWR VPWR sky130_fd_sc_hd__decap_3
XFILLER_50_519 VGND VGND VPWR VPWR sky130_fd_sc_hd__decap_3
XFILLER_62_379 VGND VGND VPWR VPWR sky130_fd_sc_hd__fill_1
XFILLER_90_699 VGND VGND VPWR VPWR sky130_fd_sc_hd__fill_1
XFILLER_15_284 VGND VGND VPWR VPWR sky130_fd_sc_hd__decap_3
XFILLER_30_232 VGND VGND VPWR VPWR sky130_fd_sc_hd__decap_3
XFILLER_30_298 VGND VGND VPWR VPWR sky130_fd_sc_hd__decap_3
XTAP_TAPCELL_ROW_41_772 VGND VPWR sky130_fd_sc_hd__tapvpwrvgnd_1
Xclkbuf_leaf_10_clk clkbuf_leaf_9_clk/A VGND VGND VPWR VPWR _6943_/CLK sky130_fd_sc_hd__clkbuf_16
X_4540_ _4540_/A _4563_/B VGND VGND VPWR VPWR _7310_/D sky130_fd_sc_hd__and2_2
XFILLER_116_337 VGND VGND VPWR VPWR sky130_fd_sc_hd__fill_2
XFILLER_7_472 VGND VGND VPWR VPWR sky130_fd_sc_hd__decap_3
X_4471_ _7343_/Q _4470_/X _4471_/S VGND VGND VPWR VPWR _7343_/D sky130_fd_sc_hd__mux2_2
XFILLER_116_348 VGND VGND VPWR VPWR sky130_fd_sc_hd__fill_1
X_7190_ _7350_/CLK _7190_/D _6470_/Y VGND VGND VPWR VPWR _7190_/Q sky130_fd_sc_hd__dfrtp_2
XFILLER_99_80 VGND VGND VPWR VPWR sky130_fd_sc_hd__decap_3
XFILLER_97_210 VGND VGND VPWR VPWR sky130_fd_sc_hd__decap_3
X_3353_ _3365_/A _5129_/B VGND VGND VPWR VPWR _5668_/A sky130_fd_sc_hd__xor2_2
XFILLER_112_565 VGND VGND VPWR VPWR sky130_fd_sc_hd__decap_3
XFILLER_58_619 VGND VGND VPWR VPWR sky130_fd_sc_hd__decap_3
XFILLER_85_405 VGND VGND VPWR VPWR sky130_fd_sc_hd__fill_1
Xhold1106 _7390_/Q VGND VGND VPWR VPWR _3818_/A1 sky130_fd_sc_hd__dlygate4sd3_1
XFILLER_112_598 VGND VGND VPWR VPWR sky130_fd_sc_hd__decap_3
XFILLER_78_490 VGND VGND VPWR VPWR sky130_fd_sc_hd__decap_3
XFILLER_85_438 VGND VGND VPWR VPWR sky130_fd_sc_hd__fill_1
XFILLER_85_449 VGND VGND VPWR VPWR sky130_fd_sc_hd__decap_3
XFILLER_97_287 VGND VGND VPWR VPWR sky130_fd_sc_hd__decap_3
Xhold1117 _7397_/Q VGND VGND VPWR VPWR _3754_/A1 sky130_fd_sc_hd__dlygate4sd3_1
Xhold1128 _7239_/Q VGND VGND VPWR VPWR _5177_/A sky130_fd_sc_hd__dlygate4sd3_1
Xhold1139 _7338_/Q VGND VGND VPWR VPWR _4482_/A0 sky130_fd_sc_hd__dlygate4sd3_1
X_5023_ _5661_/A VGND VGND VPWR VPWR _5023_/Y sky130_fd_sc_hd__inv_2
XFILLER_66_641 VGND VGND VPWR VPWR sky130_fd_sc_hd__decap_3
XFILLER_66_663 VGND VGND VPWR VPWR sky130_fd_sc_hd__decap_3
XFILLER_38_398 VGND VGND VPWR VPWR sky130_fd_sc_hd__fill_1
XFILLER_53_302 VGND VGND VPWR VPWR sky130_fd_sc_hd__decap_3
XFILLER_66_696 VGND VGND VPWR VPWR sky130_fd_sc_hd__decap_3
XFILLER_81_611 VGND VGND VPWR VPWR sky130_fd_sc_hd__decap_3
XTAP_TAPCELL_ROW_49_872 VGND VPWR sky130_fd_sc_hd__tapvpwrvgnd_1
XFILLER_53_346 VGND VGND VPWR VPWR sky130_fd_sc_hd__fill_2
XFILLER_80_121 VGND VGND VPWR VPWR sky130_fd_sc_hd__decap_3
XFILLER_81_644 VGND VGND VPWR VPWR sky130_fd_sc_hd__decap_3
X_6974_ clkload8/A _6974_/D VGND VGND VPWR VPWR _6974_/Q sky130_fd_sc_hd__dfxtp_2
XFILLER_110_26 VGND VGND VPWR VPWR sky130_fd_sc_hd__fill_2
XFILLER_41_508 VGND VGND VPWR VPWR sky130_fd_sc_hd__fill_1
XFILLER_81_688 VGND VGND VPWR VPWR sky130_fd_sc_hd__decap_3
XFILLER_110_59 VGND VGND VPWR VPWR sky130_fd_sc_hd__decap_3
XTAP_TAPCELL_ROW_101_1517 VGND VPWR sky130_fd_sc_hd__tapvpwrvgnd_1
XFILLER_21_254 VGND VGND VPWR VPWR sky130_fd_sc_hd__decap_3
X_4807_ _4807_/A0 _4806_/X _4865_/S VGND VGND VPWR VPWR _7273_/D sky130_fd_sc_hd__mux2_2
XPHY_EDGE_ROW_3_Right_3 VGND VGND VPWR VPWR sky130_fd_sc_hd__decap_3
XFILLER_119_24 VGND VGND VPWR VPWR sky130_fd_sc_hd__decap_3
X_4738_ _4738_/A _4738_/B VGND VGND VPWR VPWR _7006_/D sky130_fd_sc_hd__nor2_2
XFILLER_107_315 VGND VGND VPWR VPWR sky130_fd_sc_hd__decap_3
XFILLER_107_337 VGND VGND VPWR VPWR sky130_fd_sc_hd__decap_3
XFILLER_119_175 VGND VGND VPWR VPWR sky130_fd_sc_hd__decap_3
XFILLER_119_186 VGND VGND VPWR VPWR sky130_fd_sc_hd__decap_3
XFILLER_119_197 VGND VGND VPWR VPWR sky130_fd_sc_hd__decap_3
XFILLER_119_57 VGND VGND VPWR VPWR sky130_fd_sc_hd__fill_1
X_4669_ _6995_/Q _4690_/B VGND VGND VPWR VPWR _4928_/B sky130_fd_sc_hd__and2_2
Xhold940 _6942_/Q VGND VGND VPWR VPWR _6942_/D sky130_fd_sc_hd__dlygate4sd3_1
X_6408_ _6624_/A VGND VGND VPWR VPWR _6408_/Y sky130_fd_sc_hd__inv_2
XFILLER_1_615 VGND VGND VPWR VPWR sky130_fd_sc_hd__fill_1
XFILLER_1_626 VGND VGND VPWR VPWR sky130_fd_sc_hd__decap_3
XFILLER_89_700 VGND VGND VPWR VPWR sky130_fd_sc_hd__decap_3
X_7388_ _7388_/CLK _7388_/D _6668_/Y VGND VGND VPWR VPWR _7388_/Q sky130_fd_sc_hd__dfrtp_2
Xhold951 _7115_/Q VGND VGND VPWR VPWR _7115_/D sky130_fd_sc_hd__dlygate4sd3_1
Xhold962 _7117_/Q VGND VGND VPWR VPWR _7117_/D sky130_fd_sc_hd__dlygate4sd3_1
Xhold973 _7096_/Q VGND VGND VPWR VPWR _7096_/D sky130_fd_sc_hd__dlygate4sd3_1
Xmax_cap670 _3605_/Y VGND VGND VPWR VPWR _5103_/A1 sky130_fd_sc_hd__buf_2
XFILLER_1_659 VGND VGND VPWR VPWR sky130_fd_sc_hd__decap_3
XFILLER_88_221 VGND VGND VPWR VPWR sky130_fd_sc_hd__decap_3
Xhold995 _7098_/Q VGND VGND VPWR VPWR _7098_/D sky130_fd_sc_hd__dlygate4sd3_1
Xhold984 _7083_/Q VGND VGND VPWR VPWR _7083_/D sky130_fd_sc_hd__dlygate4sd3_1
X_6339_ _6533_/A VGND VGND VPWR VPWR _6339_/Y sky130_fd_sc_hd__inv_2
XTAP_TAPCELL_ROW_112_1657 VGND VPWR sky130_fd_sc_hd__tapvpwrvgnd_1
XFILLER_49_608 VGND VGND VPWR VPWR sky130_fd_sc_hd__decap_3
XFILLER_88_265 VGND VGND VPWR VPWR sky130_fd_sc_hd__decap_3
XFILLER_28_32 VGND VGND VPWR VPWR sky130_fd_sc_hd__decap_3
XFILLER_29_310 VGND VGND VPWR VPWR sky130_fd_sc_hd__decap_3
XFILLER_48_118 VGND VGND VPWR VPWR sky130_fd_sc_hd__decap_3
XFILLER_69_490 VGND VGND VPWR VPWR sky130_fd_sc_hd__decap_3
XFILLER_76_438 VGND VGND VPWR VPWR sky130_fd_sc_hd__decap_3
XFILLER_88_298 VGND VGND VPWR VPWR sky130_fd_sc_hd__decap_3
XFILLER_95_49 VGND VGND VPWR VPWR sky130_fd_sc_hd__decap_3
XFILLER_28_65 VGND VGND VPWR VPWR sky130_fd_sc_hd__decap_3
XFILLER_29_343 VGND VGND VPWR VPWR sky130_fd_sc_hd__decap_3
XFILLER_57_641 VGND VGND VPWR VPWR sky130_fd_sc_hd__decap_3
XFILLER_29_376 VGND VGND VPWR VPWR sky130_fd_sc_hd__decap_3
XFILLER_57_685 VGND VGND VPWR VPWR sky130_fd_sc_hd__decap_3
XFILLER_72_622 VGND VGND VPWR VPWR sky130_fd_sc_hd__decap_3
XFILLER_84_471 VGND VGND VPWR VPWR sky130_fd_sc_hd__decap_3
XFILLER_44_346 VGND VGND VPWR VPWR sky130_fd_sc_hd__fill_1
XFILLER_56_184 VGND VGND VPWR VPWR sky130_fd_sc_hd__decap_3
XFILLER_72_666 VGND VGND VPWR VPWR sky130_fd_sc_hd__decap_3
XFILLER_13_700 VGND VGND VPWR VPWR sky130_fd_sc_hd__decap_3
XFILLER_71_165 VGND VGND VPWR VPWR sky130_fd_sc_hd__decap_3
XFILLER_72_699 VGND VGND VPWR VPWR sky130_fd_sc_hd__fill_1
XFILLER_71_187 VGND VGND VPWR VPWR sky130_fd_sc_hd__decap_3
XTAP_TAPCELL_ROW_27_599 VGND VPWR sky130_fd_sc_hd__tapvpwrvgnd_1
XFILLER_40_563 VGND VGND VPWR VPWR sky130_fd_sc_hd__decap_3
XFILLER_44_97 VGND VGND VPWR VPWR sky130_fd_sc_hd__fill_1
XFILLER_12_287 VGND VGND VPWR VPWR sky130_fd_sc_hd__fill_1
XFILLER_8_214 VGND VGND VPWR VPWR sky130_fd_sc_hd__decap_3
XFILLER_60_85 VGND VGND VPWR VPWR sky130_fd_sc_hd__decap_3
XTAP_TAPCELL_ROW_78_1232 VGND VPWR sky130_fd_sc_hd__tapvpwrvgnd_1
XFILLER_99_508 VGND VGND VPWR VPWR sky130_fd_sc_hd__decap_3
XFILLER_113_318 VGND VGND VPWR VPWR sky130_fd_sc_hd__decap_3
XFILLER_4_486 VGND VGND VPWR VPWR sky130_fd_sc_hd__decap_3
XFILLER_106_392 VGND VGND VPWR VPWR sky130_fd_sc_hd__decap_3
XFILLER_67_405 VGND VGND VPWR VPWR sky130_fd_sc_hd__decap_3
XFILLER_79_243 VGND VGND VPWR VPWR sky130_fd_sc_hd__decap_3
XFILLER_95_703 VGND VGND VPWR VPWR sky130_fd_sc_hd__decap_3
XFILLER_67_438 VGND VGND VPWR VPWR sky130_fd_sc_hd__fill_2
XFILLER_67_449 VGND VGND VPWR VPWR sky130_fd_sc_hd__fill_1
XFILLER_79_287 VGND VGND VPWR VPWR sky130_fd_sc_hd__decap_3
XFILLER_94_235 VGND VGND VPWR VPWR sky130_fd_sc_hd__decap_3
XFILLER_48_641 VGND VGND VPWR VPWR sky130_fd_sc_hd__decap_3
XFILLER_48_663 VGND VGND VPWR VPWR sky130_fd_sc_hd__decap_3
XFILLER_85_60 VGND VGND VPWR VPWR sky130_fd_sc_hd__decap_3
XFILLER_47_162 VGND VGND VPWR VPWR sky130_fd_sc_hd__decap_3
XFILLER_48_696 VGND VGND VPWR VPWR sky130_fd_sc_hd__decap_3
XFILLER_85_93 VGND VGND VPWR VPWR sky130_fd_sc_hd__decap_3
XTAP_TAPCELL_ROW_89_1372 VGND VPWR sky130_fd_sc_hd__tapvpwrvgnd_1
XFILLER_47_184 VGND VGND VPWR VPWR sky130_fd_sc_hd__decap_3
XFILLER_63_644 VGND VGND VPWR VPWR sky130_fd_sc_hd__decap_3
XFILLER_90_430 VGND VGND VPWR VPWR sky130_fd_sc_hd__decap_3
XTAP_TAPCELL_ROW_46_831 VGND VPWR sky130_fd_sc_hd__tapvpwrvgnd_1
XFILLER_23_508 VGND VGND VPWR VPWR sky130_fd_sc_hd__decap_3
XFILLER_63_688 VGND VGND VPWR VPWR sky130_fd_sc_hd__decap_3
X_5710_ _7361_/Q _5710_/A1 _5737_/S VGND VGND VPWR VPWR _6705_/D sky130_fd_sc_hd__mux2_2
XFILLER_93_3 VGND VGND VPWR VPWR sky130_fd_sc_hd__decap_3
X_6690_ _7355_/CLK _6690_/D VGND VGND VPWR VPWR _6690_/Q sky130_fd_sc_hd__dfxtp_2
XFILLER_31_574 VGND VGND VPWR VPWR sky130_fd_sc_hd__decap_3
X_5641_ _5641_/A VGND VGND VPWR VPWR _5641_/Y sky130_fd_sc_hd__inv_2
X_5572_ _5572_/A1 _4960_/A _4961_/C VGND VGND VPWR VPWR _7045_/D sky130_fd_sc_hd__a21o_2
XFILLER_117_635 VGND VGND VPWR VPWR sky130_fd_sc_hd__decap_3
X_7311_ _7349_/CLK _7311_/D _6591_/Y VGND VGND VPWR VPWR _7311_/Q sky130_fd_sc_hd__dfrtp_2
XFILLER_117_668 VGND VGND VPWR VPWR sky130_fd_sc_hd__decap_3
XFILLER_117_679 VGND VGND VPWR VPWR sky130_fd_sc_hd__decap_3
X_7242_ _7402_/CLK _7242_/D _6522_/Y VGND VGND VPWR VPWR _7242_/Q sky130_fd_sc_hd__dfrtp_2
XFILLER_104_318 VGND VGND VPWR VPWR sky130_fd_sc_hd__decap_3
XFILLER_116_189 VGND VGND VPWR VPWR sky130_fd_sc_hd__decap_3
X_4454_ _4761_/B _4761_/C _4745_/A _4762_/B VGND VGND VPWR VPWR _4454_/X sky130_fd_sc_hd__a211o_2
X_7173_ _7370_/CLK _7173_/D _6453_/Y VGND VGND VPWR VPWR _7173_/Q sky130_fd_sc_hd__dfrtp_2
X_4385_ _7337_/Q _3945_/S _4428_/B1 _7145_/Q VGND VGND VPWR VPWR _4385_/X sky130_fd_sc_hd__a22o_2
X_3405_ _3340_/A _6983_/Q _3340_/C _5602_/B VGND VGND VPWR VPWR _3409_/D sky130_fd_sc_hd__o31a_2
XFILLER_105_15 VGND VGND VPWR VPWR sky130_fd_sc_hd__decap_3
XFILLER_98_563 VGND VGND VPWR VPWR sky130_fd_sc_hd__decap_3
XFILLER_100_513 VGND VGND VPWR VPWR sky130_fd_sc_hd__decap_3
XFILLER_85_213 VGND VGND VPWR VPWR sky130_fd_sc_hd__decap_3
XFILLER_98_585 VGND VGND VPWR VPWR sky130_fd_sc_hd__decap_3
XFILLER_39_641 VGND VGND VPWR VPWR sky130_fd_sc_hd__decap_3
XFILLER_85_246 VGND VGND VPWR VPWR sky130_fd_sc_hd__decap_3
X_5006_ _5114_/A _4626_/X _5003_/A _5033_/B2 VGND VGND VPWR VPWR _5006_/X sky130_fd_sc_hd__a22o_2
XFILLER_26_302 VGND VGND VPWR VPWR sky130_fd_sc_hd__decap_3
XFILLER_38_173 VGND VGND VPWR VPWR sky130_fd_sc_hd__decap_3
XFILLER_39_685 VGND VGND VPWR VPWR sky130_fd_sc_hd__decap_3
XFILLER_66_471 VGND VGND VPWR VPWR sky130_fd_sc_hd__decap_3
XFILLER_26_335 VGND VGND VPWR VPWR sky130_fd_sc_hd__decap_3
XFILLER_53_110 VGND VGND VPWR VPWR sky130_fd_sc_hd__fill_2
XFILLER_54_633 VGND VGND VPWR VPWR sky130_fd_sc_hd__decap_3
XFILLER_81_441 VGND VGND VPWR VPWR sky130_fd_sc_hd__fill_1
XFILLER_93_290 VGND VGND VPWR VPWR sky130_fd_sc_hd__decap_3
XFILLER_26_357 VGND VGND VPWR VPWR sky130_fd_sc_hd__decap_3
XFILLER_41_305 VGND VGND VPWR VPWR sky130_fd_sc_hd__decap_3
XFILLER_54_666 VGND VGND VPWR VPWR sky130_fd_sc_hd__decap_3
XFILLER_81_452 VGND VGND VPWR VPWR sky130_fd_sc_hd__decap_3
X_6957_ clkload6/A _6957_/D VGND VGND VPWR VPWR _6957_/Q sky130_fd_sc_hd__dfxtp_2
XFILLER_41_349 VGND VGND VPWR VPWR sky130_fd_sc_hd__fill_1
XFILLER_54_699 VGND VGND VPWR VPWR sky130_fd_sc_hd__fill_1
X_6888_ clkload9/A _6888_/D VGND VGND VPWR VPWR _6888_/Q sky130_fd_sc_hd__dfxtp_2
XTAP_TAPCELL_ROW_62_1033 VGND VPWR sky130_fd_sc_hd__tapvpwrvgnd_1
XTAP_TAPCELL_ROW_24_558 VGND VPWR sky130_fd_sc_hd__tapvpwrvgnd_1
XFILLER_22_585 VGND VGND VPWR VPWR sky130_fd_sc_hd__decap_3
XFILLER_6_707 VGND VGND VPWR VPWR sky130_fd_sc_hd__decap_3
XFILLER_108_613 VGND VGND VPWR VPWR sky130_fd_sc_hd__decap_3
XFILLER_30_22 VGND VGND VPWR VPWR sky130_fd_sc_hd__decap_3
XFILLER_107_134 VGND VGND VPWR VPWR sky130_fd_sc_hd__decap_3
XFILLER_108_657 VGND VGND VPWR VPWR sky130_fd_sc_hd__decap_3
XFILLER_107_167 VGND VGND VPWR VPWR sky130_fd_sc_hd__fill_1
XFILLER_116_690 VGND VGND VPWR VPWR sky130_fd_sc_hd__decap_3
Xhold770 _6840_/Q VGND VGND VPWR VPWR _6840_/D sky130_fd_sc_hd__dlygate4sd3_1
Xhold781 _6951_/Q VGND VGND VPWR VPWR _6951_/D sky130_fd_sc_hd__dlygate4sd3_1
XFILLER_103_351 VGND VGND VPWR VPWR sky130_fd_sc_hd__decap_3
XFILLER_1_445 VGND VGND VPWR VPWR sky130_fd_sc_hd__decap_3
XFILLER_39_31 VGND VGND VPWR VPWR sky130_fd_sc_hd__decap_3
XFILLER_77_703 VGND VGND VPWR VPWR sky130_fd_sc_hd__decap_3
Xhold792 _6976_/Q VGND VGND VPWR VPWR _6976_/D sky130_fd_sc_hd__dlygate4sd3_1
XTAP_TAPCELL_ROW_73_1173 VGND VPWR sky130_fd_sc_hd__tapvpwrvgnd_1
XFILLER_103_362 VGND VGND VPWR VPWR sky130_fd_sc_hd__decap_3
XFILLER_1_478 VGND VGND VPWR VPWR sky130_fd_sc_hd__decap_3
XFILLER_49_449 VGND VGND VPWR VPWR sky130_fd_sc_hd__fill_1
XFILLER_76_213 VGND VGND VPWR VPWR sky130_fd_sc_hd__decap_3
XFILLER_39_86 VGND VGND VPWR VPWR sky130_fd_sc_hd__decap_3
XFILLER_76_246 VGND VGND VPWR VPWR sky130_fd_sc_hd__decap_3
XFILLER_29_162 VGND VGND VPWR VPWR sky130_fd_sc_hd__decap_3
XFILLER_45_611 VGND VGND VPWR VPWR sky130_fd_sc_hd__decap_3
XFILLER_91_205 VGND VGND VPWR VPWR sky130_fd_sc_hd__decap_3
XFILLER_17_346 VGND VGND VPWR VPWR sky130_fd_sc_hd__decap_3
XFILLER_29_184 VGND VGND VPWR VPWR sky130_fd_sc_hd__decap_3
XFILLER_45_644 VGND VGND VPWR VPWR sky130_fd_sc_hd__decap_3
XFILLER_55_52 VGND VGND VPWR VPWR sky130_fd_sc_hd__decap_3
XFILLER_84_290 VGND VGND VPWR VPWR sky130_fd_sc_hd__decap_3
XFILLER_32_305 VGND VGND VPWR VPWR sky130_fd_sc_hd__decap_3
XFILLER_45_688 VGND VGND VPWR VPWR sky130_fd_sc_hd__decap_3
XFILLER_55_74 VGND VGND VPWR VPWR sky130_fd_sc_hd__fill_1
XTAP_TAPCELL_ROW_43_801 VGND VPWR sky130_fd_sc_hd__tapvpwrvgnd_1
XFILLER_60_625 VGND VGND VPWR VPWR sky130_fd_sc_hd__decap_3
XFILLER_32_349 VGND VGND VPWR VPWR sky130_fd_sc_hd__decap_3
XFILLER_60_669 VGND VGND VPWR VPWR sky130_fd_sc_hd__decap_3
XFILLER_13_585 VGND VGND VPWR VPWR sky130_fd_sc_hd__decap_3
XFILLER_9_567 VGND VGND VPWR VPWR sky130_fd_sc_hd__decap_3
XFILLER_114_616 VGND VGND VPWR VPWR sky130_fd_sc_hd__decap_3
XFILLER_99_327 VGND VGND VPWR VPWR sky130_fd_sc_hd__decap_3
XFILLER_4_283 VGND VGND VPWR VPWR sky130_fd_sc_hd__fill_1
XFILLER_4_294 VGND VGND VPWR VPWR sky130_fd_sc_hd__decap_3
X_4170_ _4203_/A _4203_/B _4202_/A VGND VGND VPWR VPWR _4938_/B sky130_fd_sc_hd__and3_2
XFILLER_67_213 VGND VGND VPWR VPWR sky130_fd_sc_hd__decap_3
XFILLER_83_706 VGND VGND VPWR VPWR sky130_fd_sc_hd__decap_3
XFILLER_67_268 VGND VGND VPWR VPWR sky130_fd_sc_hd__decap_3
XFILLER_82_216 VGND VGND VPWR VPWR sky130_fd_sc_hd__decap_3
XFILLER_95_588 VGND VGND VPWR VPWR sky130_fd_sc_hd__decap_3
XFILLER_35_110 VGND VGND VPWR VPWR sky130_fd_sc_hd__fill_2
XFILLER_36_622 VGND VGND VPWR VPWR sky130_fd_sc_hd__decap_3
XFILLER_82_249 VGND VGND VPWR VPWR sky130_fd_sc_hd__decap_3
XFILLER_35_154 VGND VGND VPWR VPWR sky130_fd_sc_hd__decap_3
XFILLER_36_666 VGND VGND VPWR VPWR sky130_fd_sc_hd__decap_3
XFILLER_63_441 VGND VGND VPWR VPWR sky130_fd_sc_hd__decap_3
Xplace430 _3991_/A VGND VGND VPWR VPWR _4770_/A1 sky130_fd_sc_hd__buf_2
X_6811_ clkload3/A _6811_/D VGND VGND VPWR VPWR _6811_/Q sky130_fd_sc_hd__dfxtp_2
XFILLER_35_187 VGND VGND VPWR VPWR sky130_fd_sc_hd__decap_3
XFILLER_36_699 VGND VGND VPWR VPWR sky130_fd_sc_hd__fill_1
XFILLER_51_647 VGND VGND VPWR VPWR sky130_fd_sc_hd__decap_3
Xplace474 _3964_/S VGND VGND VPWR VPWR _3947_/S sky130_fd_sc_hd__buf_2
Xplace463 _3380_/Y VGND VGND VPWR VPWR _4285_/B1 sky130_fd_sc_hd__buf_2
Xplace452 _3562_/A VGND VGND VPWR VPWR _4528_/B sky130_fd_sc_hd__buf_2
Xplace441 _5211_/B VGND VGND VPWR VPWR _5207_/B sky130_fd_sc_hd__buf_2
Xplace485 _4421_/B1 VGND VGND VPWR VPWR _4459_/C1 sky130_fd_sc_hd__buf_2
Xplace496 _5587_/B VGND VGND VPWR VPWR _4960_/A sky130_fd_sc_hd__buf_2
X_6742_ clkload6/A _6742_/D VGND VGND VPWR VPWR _6742_/Q sky130_fd_sc_hd__dfxtp_2
X_3954_ _7363_/Q _4497_/A0 _3954_/S VGND VGND VPWR VPWR _7363_/D sky130_fd_sc_hd__mux2_2
XFILLER_31_360 VGND VGND VPWR VPWR sky130_fd_sc_hd__decap_3
XFILLER_50_179 VGND VGND VPWR VPWR sky130_fd_sc_hd__decap_3
X_6673_ _6677_/A VGND VGND VPWR VPWR _6673_/Y sky130_fd_sc_hd__inv_2
X_3885_ _3746_/X _3882_/X _3884_/X _3725_/X VGND VGND VPWR VPWR _3885_/X sky130_fd_sc_hd__a22o_2
XTAP_TAPCELL_ROW_21_517 VGND VPWR sky130_fd_sc_hd__tapvpwrvgnd_1
X_5624_ _5624_/A _5633_/B VGND VGND VPWR VPWR _7016_/D sky130_fd_sc_hd__or2_2
XFILLER_105_638 VGND VGND VPWR VPWR sky130_fd_sc_hd__decap_3
X_7225_ _7322_/CLK _7225_/D _6505_/Y VGND VGND VPWR VPWR _7225_/Q sky130_fd_sc_hd__dfrtp_2
X_4437_ _7022_/Q _4437_/A2 _4437_/B1 _7399_/Q _4436_/X VGND VGND VPWR VPWR _4437_/X
+ sky130_fd_sc_hd__a221o_2
XFILLER_104_159 VGND VGND VPWR VPWR sky130_fd_sc_hd__decap_3
XFILLER_116_47 VGND VGND VPWR VPWR sky130_fd_sc_hd__decap_3
XFILLER_59_703 VGND VGND VPWR VPWR sky130_fd_sc_hd__decap_3
X_7156_ _7345_/CLK _7156_/D _6436_/Y VGND VGND VPWR VPWR _7156_/Q sky130_fd_sc_hd__dfrtp_2
XFILLER_113_671 VGND VGND VPWR VPWR sky130_fd_sc_hd__fill_1
XFILLER_113_682 VGND VGND VPWR VPWR sky130_fd_sc_hd__decap_3
XFILLER_58_224 VGND VGND VPWR VPWR sky130_fd_sc_hd__decap_3
XFILLER_76_18 VGND VGND VPWR VPWR sky130_fd_sc_hd__fill_2
XFILLER_76_29 VGND VGND VPWR VPWR sky130_fd_sc_hd__decap_3
XFILLER_86_533 VGND VGND VPWR VPWR sky130_fd_sc_hd__decap_3
XFILLER_98_382 VGND VGND VPWR VPWR sky130_fd_sc_hd__decap_3
X_4368_ _5073_/A _4366_/X _5054_/A VGND VGND VPWR VPWR _4369_/B sky130_fd_sc_hd__a21oi_2
XFILLER_112_192 VGND VGND VPWR VPWR sky130_fd_sc_hd__decap_3
X_7087_ _7345_/CLK _7087_/D _6367_/Y VGND VGND VPWR VPWR _7087_/Q sky130_fd_sc_hd__dfstp_2
X_4299_ _3620_/A _4292_/X _4298_/X VGND VGND VPWR VPWR _5100_/B sky130_fd_sc_hd__a21o_2
X_3319_ _3378_/A _5646_/A _5647_/A _5647_/B VGND VGND VPWR VPWR _3319_/X sky130_fd_sc_hd__and4b_4
XFILLER_100_354 VGND VGND VPWR VPWR sky130_fd_sc_hd__fill_2
XFILLER_100_387 VGND VGND VPWR VPWR sky130_fd_sc_hd__decap_3
XFILLER_27_600 VGND VGND VPWR VPWR sky130_fd_sc_hd__decap_3
XFILLER_46_419 VGND VGND VPWR VPWR sky130_fd_sc_hd__fill_1
XTAP_TAPCELL_ROW_29_617 VGND VPWR sky130_fd_sc_hd__tapvpwrvgnd_1
XFILLER_27_644 VGND VGND VPWR VPWR sky130_fd_sc_hd__decap_3
XFILLER_54_430 VGND VGND VPWR VPWR sky130_fd_sc_hd__decap_3
XFILLER_26_132 VGND VGND VPWR VPWR sky130_fd_sc_hd__decap_3
XFILLER_27_688 VGND VGND VPWR VPWR sky130_fd_sc_hd__decap_3
XFILLER_42_603 VGND VGND VPWR VPWR sky130_fd_sc_hd__decap_3
XTAP_TAPCELL_ROW_1_275 VGND VPWR sky130_fd_sc_hd__tapvpwrvgnd_1
XFILLER_26_187 VGND VGND VPWR VPWR sky130_fd_sc_hd__decap_3
XFILLER_41_113 VGND VGND VPWR VPWR sky130_fd_sc_hd__decap_3
XFILLER_42_636 VGND VGND VPWR VPWR sky130_fd_sc_hd__decap_3
XFILLER_14_349 VGND VGND VPWR VPWR sky130_fd_sc_hd__decap_3
XFILLER_41_157 VGND VGND VPWR VPWR sky130_fd_sc_hd__decap_3
XFILLER_42_669 VGND VGND VPWR VPWR sky130_fd_sc_hd__decap_3
XFILLER_41_179 VGND VGND VPWR VPWR sky130_fd_sc_hd__fill_1
XFILLER_10_533 VGND VGND VPWR VPWR sky130_fd_sc_hd__fill_1
XFILLER_10_566 VGND VGND VPWR VPWR sky130_fd_sc_hd__decap_3
XFILLER_41_54 VGND VGND VPWR VPWR sky130_fd_sc_hd__fill_2
XFILLER_108_421 VGND VGND VPWR VPWR sky130_fd_sc_hd__decap_3
XFILLER_41_87 VGND VGND VPWR VPWR sky130_fd_sc_hd__decap_3
XFILLER_6_548 VGND VGND VPWR VPWR sky130_fd_sc_hd__decap_3
XFILLER_2_710 VGND VGND VPWR VPWR sky130_fd_sc_hd__decap_3
XFILLER_104_660 VGND VGND VPWR VPWR sky130_fd_sc_hd__decap_3
XFILLER_1_242 VGND VGND VPWR VPWR sky130_fd_sc_hd__decap_3
XTAP_TAPCELL_ROW_9_375 VGND VPWR sky130_fd_sc_hd__tapvpwrvgnd_1
XFILLER_104_693 VGND VGND VPWR VPWR sky130_fd_sc_hd__decap_3
XFILLER_110_118 VGND VGND VPWR VPWR sky130_fd_sc_hd__decap_3
XFILLER_49_213 VGND VGND VPWR VPWR sky130_fd_sc_hd__decap_3
XFILLER_77_511 VGND VGND VPWR VPWR sky130_fd_sc_hd__decap_3
XFILLER_103_192 VGND VGND VPWR VPWR sky130_fd_sc_hd__decap_3
XFILLER_65_706 VGND VGND VPWR VPWR sky130_fd_sc_hd__decap_3
XFILLER_89_393 VGND VGND VPWR VPWR sky130_fd_sc_hd__decap_3
XFILLER_64_216 VGND VGND VPWR VPWR sky130_fd_sc_hd__decap_3
XFILLER_18_622 VGND VGND VPWR VPWR sky130_fd_sc_hd__decap_3
XFILLER_64_249 VGND VGND VPWR VPWR sky130_fd_sc_hd__decap_3
XFILLER_66_73 VGND VGND VPWR VPWR sky130_fd_sc_hd__fill_2
XFILLER_92_536 VGND VGND VPWR VPWR sky130_fd_sc_hd__decap_3
XTAP_TAPCELL_ROW_86_1331 VGND VPWR sky130_fd_sc_hd__tapvpwrvgnd_1
XFILLER_18_666 VGND VGND VPWR VPWR sky130_fd_sc_hd__decap_3
XFILLER_33_603 VGND VGND VPWR VPWR sky130_fd_sc_hd__decap_3
XFILLER_45_452 VGND VGND VPWR VPWR sky130_fd_sc_hd__fill_2
XFILLER_18_699 VGND VGND VPWR VPWR sky130_fd_sc_hd__fill_1
XFILLER_72_282 VGND VGND VPWR VPWR sky130_fd_sc_hd__decap_3
XFILLER_33_647 VGND VGND VPWR VPWR sky130_fd_sc_hd__decap_3
XFILLER_60_444 VGND VGND VPWR VPWR sky130_fd_sc_hd__decap_3
XFILLER_82_61 VGND VGND VPWR VPWR sky130_fd_sc_hd__decap_3
XFILLER_32_157 VGND VGND VPWR VPWR sky130_fd_sc_hd__decap_3
XFILLER_82_94 VGND VGND VPWR VPWR sky130_fd_sc_hd__decap_3
XFILLER_13_393 VGND VGND VPWR VPWR sky130_fd_sc_hd__decap_3
XFILLER_41_691 VGND VGND VPWR VPWR sky130_fd_sc_hd__decap_3
XFILLER_9_320 VGND VGND VPWR VPWR sky130_fd_sc_hd__decap_3
XFILLER_40_190 VGND VGND VPWR VPWR sky130_fd_sc_hd__decap_3
X_3670_ _3682_/A _3669_/X _4791_/A1 VGND VGND VPWR VPWR _3670_/X sky130_fd_sc_hd__a21o_2
XFILLER_9_386 VGND VGND VPWR VPWR sky130_fd_sc_hd__decap_3
XFILLER_56_3 VGND VGND VPWR VPWR sky130_fd_sc_hd__decap_3
X_5340_ _5340_/A0 _5079_/X _5340_/S VGND VGND VPWR VPWR _7161_/D sky130_fd_sc_hd__mux2_2
XTAP_TAPCELL_ROW_97_1471 VGND VPWR sky130_fd_sc_hd__tapvpwrvgnd_1
XFILLER_5_570 VGND VGND VPWR VPWR sky130_fd_sc_hd__decap_3
XFILLER_99_113 VGND VGND VPWR VPWR sky130_fd_sc_hd__decap_3
XFILLER_114_446 VGND VGND VPWR VPWR sky130_fd_sc_hd__decap_3
X_7010_ _7086_/CLK _7010_/D _6290_/Y VGND VGND VPWR VPWR _7010_/Q sky130_fd_sc_hd__dfrtp_2
X_4222_ _7356_/Q _4272_/B _4221_/X VGND VGND VPWR VPWR _4222_/X sky130_fd_sc_hd__a21o_2
XFILLER_99_157 VGND VGND VPWR VPWR sky130_fd_sc_hd__decap_3
XFILLER_68_511 VGND VGND VPWR VPWR sky130_fd_sc_hd__decap_3
XFILLER_68_533 VGND VGND VPWR VPWR sky130_fd_sc_hd__decap_3
X_4153_ _7298_/Q _5080_/S _4267_/B1 _7170_/Q _4152_/X VGND VGND VPWR VPWR _4153_/X
+ sky130_fd_sc_hd__a221o_2
XFILLER_110_663 VGND VGND VPWR VPWR sky130_fd_sc_hd__decap_3
XFILLER_83_503 VGND VGND VPWR VPWR sky130_fd_sc_hd__fill_1
XFILLER_95_374 VGND VGND VPWR VPWR sky130_fd_sc_hd__decap_3
X_4084_ _7302_/Q _4244_/B _4083_/X _4248_/A VGND VGND VPWR VPWR _4084_/X sky130_fd_sc_hd__a211o_2
XFILLER_110_696 VGND VGND VPWR VPWR sky130_fd_sc_hd__decap_3
XFILLER_55_249 VGND VGND VPWR VPWR sky130_fd_sc_hd__decap_3
XFILLER_95_396 VGND VGND VPWR VPWR sky130_fd_sc_hd__decap_3
XFILLER_102_27 VGND VGND VPWR VPWR sky130_fd_sc_hd__fill_1
XFILLER_36_463 VGND VGND VPWR VPWR sky130_fd_sc_hd__decap_3
XFILLER_71_709 VGND VGND VPWR VPWR sky130_fd_sc_hd__decap_3
XTAP_TAPCELL_ROW_54_929 VGND VPWR sky130_fd_sc_hd__tapvpwrvgnd_1
XFILLER_23_113 VGND VGND VPWR VPWR sky130_fd_sc_hd__decap_3
XFILLER_24_625 VGND VGND VPWR VPWR sky130_fd_sc_hd__decap_3
XFILLER_36_496 VGND VGND VPWR VPWR sky130_fd_sc_hd__decap_3
XFILLER_91_580 VGND VGND VPWR VPWR sky130_fd_sc_hd__decap_3
XFILLER_24_669 VGND VGND VPWR VPWR sky130_fd_sc_hd__decap_3
X_4986_ _5003_/A _5003_/B _4626_/X VGND VGND VPWR VPWR _4987_/B sky130_fd_sc_hd__a21oi_2
XFILLER_11_319 VGND VGND VPWR VPWR sky130_fd_sc_hd__fill_1
X_6725_ clkload5/A _6725_/D VGND VGND VPWR VPWR _6725_/Q sky130_fd_sc_hd__dfxtp_2
X_3937_ _7371_/Q _4480_/A0 _3945_/S VGND VGND VPWR VPWR _7371_/D sky130_fd_sc_hd__mux2_2
XTAP_TAPCELL_ROW_34_686 VGND VPWR sky130_fd_sc_hd__tapvpwrvgnd_1
XFILLER_31_190 VGND VGND VPWR VPWR sky130_fd_sc_hd__decap_3
X_6656_ _6664_/A VGND VGND VPWR VPWR _6656_/Y sky130_fd_sc_hd__inv_2
X_3868_ _3868_/A1 _3442_/A _3867_/X VGND VGND VPWR VPWR _7384_/D sky130_fd_sc_hd__a21o_2
X_6587_ _6647_/A VGND VGND VPWR VPWR _6587_/Y sky130_fd_sc_hd__inv_2
X_5607_ _5607_/A _5634_/B VGND VGND VPWR VPWR _7024_/D sky130_fd_sc_hd__and2_2
X_3799_ _6909_/Q _3892_/A2 _3890_/B1 _6853_/Q VGND VGND VPWR VPWR _3799_/X sky130_fd_sc_hd__a22o_2
XFILLER_11_57 VGND VGND VPWR VPWR sky130_fd_sc_hd__decap_3
XFILLER_117_273 VGND VGND VPWR VPWR sky130_fd_sc_hd__decap_3
XFILLER_3_529 VGND VGND VPWR VPWR sky130_fd_sc_hd__decap_3
XFILLER_105_446 VGND VGND VPWR VPWR sky130_fd_sc_hd__fill_2
XFILLER_87_28 VGND VGND VPWR VPWR sky130_fd_sc_hd__decap_3
X_7208_ _7374_/CLK _7208_/D _6488_/Y VGND VGND VPWR VPWR _7208_/Q sky130_fd_sc_hd__dfrtp_2
Xoutput661 _6985_/Q VGND VGND VPWR VPWR pc_out[8] sky130_fd_sc_hd__clkdlybuf4s25_1
Xoutput650 _7004_/Q VGND VGND VPWR VPWR pc_out[27] sky130_fd_sc_hd__clkdlybuf4s25_1
XFILLER_59_511 VGND VGND VPWR VPWR sky130_fd_sc_hd__decap_3
XTAP_TAPCELL_ROW_70_1132 VGND VPWR sky130_fd_sc_hd__tapvpwrvgnd_1
XTAP_TAPCELL_ROW_6_334 VGND VPWR sky130_fd_sc_hd__tapvpwrvgnd_1
XFILLER_99_691 VGND VGND VPWR VPWR sky130_fd_sc_hd__decap_3
XFILLER_101_641 VGND VGND VPWR VPWR sky130_fd_sc_hd__decap_3
X_7139_ _7370_/CLK _7139_/D _6419_/Y VGND VGND VPWR VPWR _7139_/Q sky130_fd_sc_hd__dfrtp_2
XFILLER_101_685 VGND VGND VPWR VPWR sky130_fd_sc_hd__decap_3
XFILLER_47_706 VGND VGND VPWR VPWR sky130_fd_sc_hd__decap_3
XTAP_TAPCELL_ROW_109_1618 VGND VPWR sky130_fd_sc_hd__tapvpwrvgnd_1
XFILLER_100_162 VGND VGND VPWR VPWR sky130_fd_sc_hd__decap_3
XFILLER_100_184 VGND VGND VPWR VPWR sky130_fd_sc_hd__decap_3
XFILLER_36_21 VGND VGND VPWR VPWR sky130_fd_sc_hd__decap_3
XFILLER_74_525 VGND VGND VPWR VPWR sky130_fd_sc_hd__decap_3
XFILLER_74_558 VGND VGND VPWR VPWR sky130_fd_sc_hd__decap_3
XFILLER_27_430 VGND VGND VPWR VPWR sky130_fd_sc_hd__decap_3
XFILLER_27_441 VGND VGND VPWR VPWR sky130_fd_sc_hd__decap_3
XFILLER_27_452 VGND VGND VPWR VPWR sky130_fd_sc_hd__fill_1
XFILLER_36_54 VGND VGND VPWR VPWR sky130_fd_sc_hd__decap_3
XFILLER_39_290 VGND VGND VPWR VPWR sky130_fd_sc_hd__decap_3
XFILLER_15_614 VGND VGND VPWR VPWR sky130_fd_sc_hd__fill_2
XFILLER_27_474 VGND VGND VPWR VPWR sky130_fd_sc_hd__fill_1
XFILLER_36_76 VGND VGND VPWR VPWR sky130_fd_sc_hd__decap_3
XFILLER_54_271 VGND VGND VPWR VPWR sky130_fd_sc_hd__decap_3
XFILLER_61_219 VGND VGND VPWR VPWR sky130_fd_sc_hd__decap_3
XFILLER_15_647 VGND VGND VPWR VPWR sky130_fd_sc_hd__decap_3
XFILLER_42_444 VGND VGND VPWR VPWR sky130_fd_sc_hd__decap_3
XFILLER_30_628 VGND VGND VPWR VPWR sky130_fd_sc_hd__decap_3
XFILLER_42_466 VGND VGND VPWR VPWR sky130_fd_sc_hd__decap_3
XFILLER_42_477 VGND VGND VPWR VPWR sky130_fd_sc_hd__decap_3
XFILLER_52_42 VGND VGND VPWR VPWR sky130_fd_sc_hd__decap_3
XFILLER_23_691 VGND VGND VPWR VPWR sky130_fd_sc_hd__decap_3
XTAP_TAPCELL_ROW_81_1272 VGND VPWR sky130_fd_sc_hd__tapvpwrvgnd_1
XFILLER_10_352 VGND VGND VPWR VPWR sky130_fd_sc_hd__fill_2
XFILLER_10_374 VGND VGND VPWR VPWR sky130_fd_sc_hd__decap_3
XFILLER_6_312 VGND VGND VPWR VPWR sky130_fd_sc_hd__decap_3
XFILLER_108_251 VGND VGND VPWR VPWR sky130_fd_sc_hd__fill_1
XFILLER_108_262 VGND VGND VPWR VPWR sky130_fd_sc_hd__decap_3
XFILLER_10_396 VGND VGND VPWR VPWR sky130_fd_sc_hd__decap_3
XFILLER_6_345 VGND VGND VPWR VPWR sky130_fd_sc_hd__decap_3
XFILLER_2_551 VGND VGND VPWR VPWR sky130_fd_sc_hd__decap_3
XFILLER_42_9 VGND VGND VPWR VPWR sky130_fd_sc_hd__fill_1
XFILLER_97_617 VGND VGND VPWR VPWR sky130_fd_sc_hd__decap_3
XFILLER_117_90 VGND VGND VPWR VPWR sky130_fd_sc_hd__decap_3
XFILLER_2_584 VGND VGND VPWR VPWR sky130_fd_sc_hd__decap_3
XFILLER_96_116 VGND VGND VPWR VPWR sky130_fd_sc_hd__decap_3
XFILLER_111_438 VGND VGND VPWR VPWR sky130_fd_sc_hd__decap_3
XFILLER_2_595 VGND VGND VPWR VPWR sky130_fd_sc_hd__decap_3
XFILLER_89_190 VGND VGND VPWR VPWR sky130_fd_sc_hd__decap_3
XFILLER_65_503 VGND VGND VPWR VPWR sky130_fd_sc_hd__fill_1
XFILLER_65_514 VGND VGND VPWR VPWR sky130_fd_sc_hd__decap_3
XFILLER_77_94 VGND VGND VPWR VPWR sky130_fd_sc_hd__decap_3
XFILLER_77_396 VGND VGND VPWR VPWR sky130_fd_sc_hd__decap_3
XFILLER_18_430 VGND VGND VPWR VPWR sky130_fd_sc_hd__decap_3
XFILLER_52_208 VGND VGND VPWR VPWR sky130_fd_sc_hd__decap_3
XFILLER_53_709 VGND VGND VPWR VPWR sky130_fd_sc_hd__decap_3
XFILLER_18_474 VGND VGND VPWR VPWR sky130_fd_sc_hd__fill_2
XFILLER_80_528 VGND VGND VPWR VPWR sky130_fd_sc_hd__fill_1
XFILLER_92_388 VGND VGND VPWR VPWR sky130_fd_sc_hd__decap_3
XFILLER_93_93 VGND VGND VPWR VPWR sky130_fd_sc_hd__decap_3
XFILLER_33_444 VGND VGND VPWR VPWR sky130_fd_sc_hd__decap_3
XFILLER_33_455 VGND VGND VPWR VPWR sky130_fd_sc_hd__decap_3
XFILLER_73_591 VGND VGND VPWR VPWR sky130_fd_sc_hd__fill_1
X_4840_ _4903_/B _4903_/C _4903_/A VGND VGND VPWR VPWR _4888_/B sky130_fd_sc_hd__a21oi_2
XFILLER_21_606 VGND VGND VPWR VPWR sky130_fd_sc_hd__decap_3
XFILLER_21_617 VGND VGND VPWR VPWR sky130_fd_sc_hd__decap_3
XFILLER_33_477 VGND VGND VPWR VPWR sky130_fd_sc_hd__fill_1
XFILLER_20_138 VGND VGND VPWR VPWR sky130_fd_sc_hd__fill_2
X_6510_ _6639_/A VGND VGND VPWR VPWR _6510_/Y sky130_fd_sc_hd__inv_2
X_4771_ _4836_/S _7005_/D _4760_/Y _4770_/X VGND VGND VPWR VPWR _4771_/X sky130_fd_sc_hd__o211a_2
XTAP_TAPCELL_ROW_99_1500 VGND VPWR sky130_fd_sc_hd__tapvpwrvgnd_1
XFILLER_119_505 VGND VGND VPWR VPWR sky130_fd_sc_hd__fill_2
XTAP_TAPCELL_ROW_31_645 VGND VPWR sky130_fd_sc_hd__tapvpwrvgnd_1
X_6441_ _6640_/A VGND VGND VPWR VPWR _6441_/Y sky130_fd_sc_hd__inv_2
XFILLER_9_172 VGND VGND VPWR VPWR sky130_fd_sc_hd__decap_3
XFILLER_115_700 VGND VGND VPWR VPWR sky130_fd_sc_hd__decap_3
X_6372_ _6563_/A VGND VGND VPWR VPWR _6372_/Y sky130_fd_sc_hd__inv_2
XTAP_TAPCELL_ROW_11_391 VGND VPWR sky130_fd_sc_hd__tapvpwrvgnd_1
X_5323_ _5323_/A0 _4945_/X _5323_/S VGND VGND VPWR VPWR _7169_/D sky130_fd_sc_hd__mux2_2
X_3584_ _3424_/S _3583_/X _5648_/B VGND VGND VPWR VPWR _3586_/D sky130_fd_sc_hd__a21oi_2
XFILLER_114_232 VGND VGND VPWR VPWR sky130_fd_sc_hd__decap_3
XFILLER_87_116 VGND VGND VPWR VPWR sky130_fd_sc_hd__decap_3
XFILLER_88_639 VGND VGND VPWR VPWR sky130_fd_sc_hd__decap_3
X_4205_ _4205_/A _4205_/B _4205_/C VGND VGND VPWR VPWR _4205_/X sky130_fd_sc_hd__and3_2
XFILLER_29_706 VGND VGND VPWR VPWR sky130_fd_sc_hd__decap_3
XFILLER_56_503 VGND VGND VPWR VPWR sky130_fd_sc_hd__decap_3
XFILLER_96_672 VGND VGND VPWR VPWR sky130_fd_sc_hd__decap_3
X_4136_ _7235_/Q _4433_/B _4914_/S _7299_/Q _4135_/X VGND VGND VPWR VPWR _4136_/X
+ sky130_fd_sc_hd__a221o_2
XFILLER_113_15 VGND VGND VPWR VPWR sky130_fd_sc_hd__decap_3
XFILLER_113_26 VGND VGND VPWR VPWR sky130_fd_sc_hd__decap_3
XFILLER_28_227 VGND VGND VPWR VPWR sky130_fd_sc_hd__decap_3
XFILLER_28_238 VGND VGND VPWR VPWR sky130_fd_sc_hd__decap_3
XFILLER_56_536 VGND VGND VPWR VPWR sky130_fd_sc_hd__decap_3
X_4067_ _4068_/A _4082_/A VGND VGND VPWR VPWR _4744_/B sky130_fd_sc_hd__and2_2
XTAP_TAPCELL_ROW_39_745 VGND VPWR sky130_fd_sc_hd__tapvpwrvgnd_1
XFILLER_43_208 VGND VGND VPWR VPWR sky130_fd_sc_hd__decap_3
XFILLER_83_388 VGND VGND VPWR VPWR sky130_fd_sc_hd__decap_3
XFILLER_36_282 VGND VGND VPWR VPWR sky130_fd_sc_hd__decap_3
XTAP_TAPCELL_ROW_19_491 VGND VPWR sky130_fd_sc_hd__tapvpwrvgnd_1
XFILLER_12_628 VGND VGND VPWR VPWR sky130_fd_sc_hd__decap_3
XFILLER_24_477 VGND VGND VPWR VPWR sky130_fd_sc_hd__decap_3
XFILLER_51_252 VGND VGND VPWR VPWR sky130_fd_sc_hd__decap_3
XTAP_TAPCELL_ROW_104_1559 VGND VPWR sky130_fd_sc_hd__tapvpwrvgnd_1
XFILLER_11_116 VGND VGND VPWR VPWR sky130_fd_sc_hd__decap_3
XFILLER_51_296 VGND VGND VPWR VPWR sky130_fd_sc_hd__fill_2
X_4969_ _4968_/Y _4969_/B _4969_/C VGND VGND VPWR VPWR _4969_/X sky130_fd_sc_hd__and3b_2
XFILLER_11_149 VGND VGND VPWR VPWR sky130_fd_sc_hd__decap_3
X_6708_ _6943_/CLK _6708_/D VGND VGND VPWR VPWR _6708_/Q sky130_fd_sc_hd__dfxtp_2
XFILLER_20_672 VGND VGND VPWR VPWR sky130_fd_sc_hd__decap_3
X_6639_ _6639_/A VGND VGND VPWR VPWR _6639_/Y sky130_fd_sc_hd__inv_2
XFILLER_3_315 VGND VGND VPWR VPWR sky130_fd_sc_hd__fill_2
XFILLER_3_337 VGND VGND VPWR VPWR sky130_fd_sc_hd__decap_3
XFILLER_105_254 VGND VGND VPWR VPWR sky130_fd_sc_hd__decap_3
XFILLER_79_617 VGND VGND VPWR VPWR sky130_fd_sc_hd__decap_3
XTAP_TAPCELL_ROW_115_1699 VGND VPWR sky130_fd_sc_hd__tapvpwrvgnd_1
XFILLER_78_127 VGND VGND VPWR VPWR sky130_fd_sc_hd__decap_3
XPHY_EDGE_ROW_110_Right_110 VGND VGND VPWR VPWR sky130_fd_sc_hd__decap_3
XFILLER_101_460 VGND VGND VPWR VPWR sky130_fd_sc_hd__decap_3
XFILLER_19_205 VGND VGND VPWR VPWR sky130_fd_sc_hd__decap_3
XFILLER_59_352 VGND VGND VPWR VPWR sky130_fd_sc_hd__decap_3
XFILLER_87_661 VGND VGND VPWR VPWR sky130_fd_sc_hd__decap_3
XFILLER_93_108 VGND VGND VPWR VPWR sky130_fd_sc_hd__decap_3
XFILLER_93_119 VGND VGND VPWR VPWR sky130_fd_sc_hd__decap_3
XFILLER_101_482 VGND VGND VPWR VPWR sky130_fd_sc_hd__decap_3
XFILLER_59_396 VGND VGND VPWR VPWR sky130_fd_sc_hd__decap_3
XFILLER_87_694 VGND VGND VPWR VPWR sky130_fd_sc_hd__decap_3
XFILLER_35_709 VGND VGND VPWR VPWR sky130_fd_sc_hd__decap_3
XFILLER_47_558 VGND VGND VPWR VPWR sky130_fd_sc_hd__fill_2
XFILLER_62_506 VGND VGND VPWR VPWR sky130_fd_sc_hd__decap_3
XFILLER_55_580 VGND VGND VPWR VPWR sky130_fd_sc_hd__decap_3
XFILLER_74_377 VGND VGND VPWR VPWR sky130_fd_sc_hd__decap_3
XTAP_TAPCELL_ROW_83_1301 VGND VPWR sky130_fd_sc_hd__tapvpwrvgnd_1
XFILLER_15_422 VGND VGND VPWR VPWR sky130_fd_sc_hd__decap_3
XFILLER_42_296 VGND VGND VPWR VPWR sky130_fd_sc_hd__decap_3
XFILLER_63_96 VGND VGND VPWR VPWR sky130_fd_sc_hd__decap_3
XFILLER_70_583 VGND VGND VPWR VPWR sky130_fd_sc_hd__fill_1
XFILLER_11_650 VGND VGND VPWR VPWR sky130_fd_sc_hd__decap_3
XFILLER_8_25 VGND VGND VPWR VPWR sky130_fd_sc_hd__decap_3
XFILLER_11_694 VGND VGND VPWR VPWR sky130_fd_sc_hd__decap_3
XFILLER_7_632 VGND VGND VPWR VPWR sky130_fd_sc_hd__decap_3
XFILLER_7_665 VGND VGND VPWR VPWR sky130_fd_sc_hd__decap_3
XFILLER_7_676 VGND VGND VPWR VPWR sky130_fd_sc_hd__decap_3
XFILLER_109_593 VGND VGND VPWR VPWR sky130_fd_sc_hd__decap_3
XTAP_TAPCELL_ROW_94_1430 VGND VPWR sky130_fd_sc_hd__tapvpwrvgnd_1
XFILLER_6_197 VGND VGND VPWR VPWR sky130_fd_sc_hd__decap_3
XFILLER_111_202 VGND VGND VPWR VPWR sky130_fd_sc_hd__fill_2
XFILLER_69_116 VGND VGND VPWR VPWR sky130_fd_sc_hd__decap_3
XFILLER_88_82 VGND VGND VPWR VPWR sky130_fd_sc_hd__fill_2
XFILLER_97_403 VGND VGND VPWR VPWR sky130_fd_sc_hd__decap_3
XFILLER_97_425 VGND VGND VPWR VPWR sky130_fd_sc_hd__decap_3
XFILLER_2_370 VGND VGND VPWR VPWR sky130_fd_sc_hd__fill_1
XFILLER_69_149 VGND VGND VPWR VPWR sky130_fd_sc_hd__decap_3
XFILLER_111_268 VGND VGND VPWR VPWR sky130_fd_sc_hd__decap_3
XFILLER_78_672 VGND VGND VPWR VPWR sky130_fd_sc_hd__decap_3
XFILLER_38_525 VGND VGND VPWR VPWR sky130_fd_sc_hd__fill_1
XFILLER_38_547 VGND VGND VPWR VPWR sky130_fd_sc_hd__decap_3
XFILLER_65_322 VGND VGND VPWR VPWR sky130_fd_sc_hd__decap_3
XFILLER_77_160 VGND VGND VPWR VPWR sky130_fd_sc_hd__decap_3
XFILLER_93_620 VGND VGND VPWR VPWR sky130_fd_sc_hd__decap_3
XFILLER_65_333 VGND VGND VPWR VPWR sky130_fd_sc_hd__decap_3
XFILLER_92_130 VGND VGND VPWR VPWR sky130_fd_sc_hd__decap_3
XFILLER_92_141 VGND VGND VPWR VPWR sky130_fd_sc_hd__fill_1
XFILLER_93_653 VGND VGND VPWR VPWR sky130_fd_sc_hd__decap_3
X_6990_ _7396_/CLK _6990_/D _6270_/Y VGND VGND VPWR VPWR _6990_/Q sky130_fd_sc_hd__dfrtp_2
XFILLER_92_174 VGND VGND VPWR VPWR sky130_fd_sc_hd__decap_3
XFILLER_93_697 VGND VGND VPWR VPWR sky130_fd_sc_hd__decap_3
XTAP_TAPCELL_ROW_36_704 VGND VPWR sky130_fd_sc_hd__tapvpwrvgnd_1
XFILLER_18_293 VGND VGND VPWR VPWR sky130_fd_sc_hd__decap_3
XFILLER_33_263 VGND VGND VPWR VPWR sky130_fd_sc_hd__decap_3
XFILLER_61_561 VGND VGND VPWR VPWR sky130_fd_sc_hd__decap_3
XFILLER_33_296 VGND VGND VPWR VPWR sky130_fd_sc_hd__decap_3
X_4823_ _4823_/A0 _4822_/X _4914_/S VGND VGND VPWR VPWR _7272_/D sky130_fd_sc_hd__mux2_2
XTAP_TAPCELL_ROW_16_461 VGND VPWR sky130_fd_sc_hd__tapvpwrvgnd_1
XFILLER_21_458 VGND VGND VPWR VPWR sky130_fd_sc_hd__decap_3
XFILLER_119_335 VGND VGND VPWR VPWR sky130_fd_sc_hd__fill_1
X_3705_ _3705_/A0 _3704_/X _4799_/A VGND VGND VPWR VPWR _7400_/D sky130_fd_sc_hd__mux2_2
XFILLER_119_368 VGND VGND VPWR VPWR sky130_fd_sc_hd__fill_2
X_4685_ _6996_/Q _4668_/X _4928_/B _4684_/X VGND VGND VPWR VPWR _4858_/B sky130_fd_sc_hd__a31o_2
XFILLER_108_15 VGND VGND VPWR VPWR sky130_fd_sc_hd__decap_3
X_6424_ _6648_/A VGND VGND VPWR VPWR _6424_/Y sky130_fd_sc_hd__inv_2
X_3636_ _3636_/A _3636_/B VGND VGND VPWR VPWR _3636_/Y sky130_fd_sc_hd__nor2_2
XFILLER_108_59 VGND VGND VPWR VPWR sky130_fd_sc_hd__decap_3
XFILLER_115_530 VGND VGND VPWR VPWR sky130_fd_sc_hd__decap_3
X_6355_ _6683_/A VGND VGND VPWR VPWR _6355_/Y sky130_fd_sc_hd__inv_2
X_3567_ _7221_/Q _4307_/A2 _4285_/A2 _7034_/Q _3566_/X VGND VGND VPWR VPWR _3567_/X
+ sky130_fd_sc_hd__a221o_2
XFILLER_0_318 VGND VGND VPWR VPWR sky130_fd_sc_hd__decap_3
XFILLER_103_703 VGND VGND VPWR VPWR sky130_fd_sc_hd__decap_3
X_6286_ _6288_/A VGND VGND VPWR VPWR _6286_/Y sky130_fd_sc_hd__inv_2
X_5306_ _5306_/A0 _4806_/X _5315_/S VGND VGND VPWR VPWR _7177_/D sky130_fd_sc_hd__mux2_2
XFILLER_102_213 VGND VGND VPWR VPWR sky130_fd_sc_hd__decap_3
XFILLER_115_596 VGND VGND VPWR VPWR sky130_fd_sc_hd__decap_3
XFILLER_88_436 VGND VGND VPWR VPWR sky130_fd_sc_hd__decap_3
X_3498_ _5104_/A _3442_/B _3449_/B VGND VGND VPWR VPWR _5152_/B sky130_fd_sc_hd__a21oi_2
XFILLER_102_268 VGND VGND VPWR VPWR sky130_fd_sc_hd__decap_3
XFILLER_69_650 VGND VGND VPWR VPWR sky130_fd_sc_hd__decap_3
XFILLER_76_609 VGND VGND VPWR VPWR sky130_fd_sc_hd__decap_3
XFILLER_88_469 VGND VGND VPWR VPWR sky130_fd_sc_hd__decap_3
XFILLER_29_514 VGND VGND VPWR VPWR sky130_fd_sc_hd__decap_3
XFILLER_68_171 VGND VGND VPWR VPWR sky130_fd_sc_hd__decap_3
XFILLER_69_694 VGND VGND VPWR VPWR sky130_fd_sc_hd__decap_3
XFILLER_84_631 VGND VGND VPWR VPWR sky130_fd_sc_hd__decap_3
XFILLER_110_290 VGND VGND VPWR VPWR sky130_fd_sc_hd__decap_3
XFILLER_17_709 VGND VGND VPWR VPWR sky130_fd_sc_hd__decap_3
XFILLER_56_333 VGND VGND VPWR VPWR sky130_fd_sc_hd__decap_3
XFILLER_83_141 VGND VGND VPWR VPWR sky130_fd_sc_hd__decap_3
X_5099_ _5099_/A _5100_/A VGND VGND VPWR VPWR _5099_/X sky130_fd_sc_hd__or2_2
X_4119_ _7236_/Q _4353_/A2 _4437_/B1 _7396_/Q _4118_/X VGND VGND VPWR VPWR _4119_/X
+ sky130_fd_sc_hd__a221o_2
XFILLER_16_219 VGND VGND VPWR VPWR sky130_fd_sc_hd__decap_3
XFILLER_44_528 VGND VGND VPWR VPWR sky130_fd_sc_hd__decap_3
XFILLER_84_675 VGND VGND VPWR VPWR sky130_fd_sc_hd__decap_3
XFILLER_71_358 VGND VGND VPWR VPWR sky130_fd_sc_hd__decap_3
XFILLER_83_196 VGND VGND VPWR VPWR sky130_fd_sc_hd__decap_3
XFILLER_24_230 VGND VGND VPWR VPWR sky130_fd_sc_hd__decap_3
XFILLER_40_701 VGND VGND VPWR VPWR sky130_fd_sc_hd__decap_3
XFILLER_52_583 VGND VGND VPWR VPWR sky130_fd_sc_hd__fill_2
XTAP_TAPCELL_ROW_65_1075 VGND VPWR sky130_fd_sc_hd__tapvpwrvgnd_1
XTAP_TAPCELL_ROW_117_1717 VGND VPWR sky130_fd_sc_hd__tapvpwrvgnd_1
XFILLER_4_602 VGND VGND VPWR VPWR sky130_fd_sc_hd__decap_3
XFILLER_4_635 VGND VGND VPWR VPWR sky130_fd_sc_hd__decap_3
XFILLER_4_657 VGND VGND VPWR VPWR sky130_fd_sc_hd__decap_3
XFILLER_3_145 VGND VGND VPWR VPWR sky130_fd_sc_hd__fill_1
XFILLER_79_414 VGND VGND VPWR VPWR sky130_fd_sc_hd__decap_3
XFILLER_79_425 VGND VGND VPWR VPWR sky130_fd_sc_hd__fill_2
XFILLER_79_458 VGND VGND VPWR VPWR sky130_fd_sc_hd__fill_1
XFILLER_67_609 VGND VGND VPWR VPWR sky130_fd_sc_hd__decap_3
XFILLER_94_417 VGND VGND VPWR VPWR sky130_fd_sc_hd__decap_3
XFILLER_58_85 VGND VGND VPWR VPWR sky130_fd_sc_hd__decap_3
XFILLER_75_620 VGND VGND VPWR VPWR sky130_fd_sc_hd__decap_3
XFILLER_74_130 VGND VGND VPWR VPWR sky130_fd_sc_hd__decap_3
XFILLER_74_141 VGND VGND VPWR VPWR sky130_fd_sc_hd__decap_3
XFILLER_75_653 VGND VGND VPWR VPWR sky130_fd_sc_hd__decap_3
XFILLER_114_80 VGND VGND VPWR VPWR sky130_fd_sc_hd__decap_3
XFILLER_114_91 VGND VGND VPWR VPWR sky130_fd_sc_hd__decap_3
XFILLER_74_174 VGND VGND VPWR VPWR sky130_fd_sc_hd__decap_3
XFILLER_75_697 VGND VGND VPWR VPWR sky130_fd_sc_hd__decap_3
XFILLER_47_399 VGND VGND VPWR VPWR sky130_fd_sc_hd__decap_3
XFILLER_62_336 VGND VGND VPWR VPWR sky130_fd_sc_hd__decap_3
XFILLER_74_62 VGND VGND VPWR VPWR sky130_fd_sc_hd__decap_3
XFILLER_90_634 VGND VGND VPWR VPWR sky130_fd_sc_hd__decap_3
XFILLER_90_645 VGND VGND VPWR VPWR sky130_fd_sc_hd__decap_3
XFILLER_31_712 VGND VGND VPWR VPWR sky130_fd_sc_hd__fill_2
XFILLER_43_561 VGND VGND VPWR VPWR sky130_fd_sc_hd__decap_3
XFILLER_90_678 VGND VGND VPWR VPWR sky130_fd_sc_hd__decap_3
XFILLER_15_296 VGND VGND VPWR VPWR sky130_fd_sc_hd__decap_3
XFILLER_30_200 VGND VGND VPWR VPWR sky130_fd_sc_hd__decap_3
XFILLER_30_244 VGND VGND VPWR VPWR sky130_fd_sc_hd__decap_3
XTAP_TAPCELL_ROW_13_420 VGND VPWR sky130_fd_sc_hd__tapvpwrvgnd_1
XFILLER_30_266 VGND VGND VPWR VPWR sky130_fd_sc_hd__decap_3
XFILLER_90_94 VGND VGND VPWR VPWR sky130_fd_sc_hd__decap_3
XTAP_TAPCELL_ROW_41_773 VGND VPWR sky130_fd_sc_hd__tapvpwrvgnd_1
XFILLER_7_440 VGND VGND VPWR VPWR sky130_fd_sc_hd__decap_3
X_4470_ _3346_/A _3927_/X _4466_/Y _4469_/X VGND VGND VPWR VPWR _4470_/X sky130_fd_sc_hd__a31o_2
X_3421_ _4537_/B _3421_/B _3421_/C VGND VGND VPWR VPWR _3423_/C sky130_fd_sc_hd__or3_4
XFILLER_112_511 VGND VGND VPWR VPWR sky130_fd_sc_hd__decap_3
X_3352_ _3420_/A _5642_/B VGND VGND VPWR VPWR _3469_/B sky130_fd_sc_hd__nor2_2
XFILLER_98_701 VGND VGND VPWR VPWR sky130_fd_sc_hd__decap_3
XFILLER_112_533 VGND VGND VPWR VPWR sky130_fd_sc_hd__fill_1
XFILLER_97_222 VGND VGND VPWR VPWR sky130_fd_sc_hd__fill_2
XFILLER_112_577 VGND VGND VPWR VPWR sky130_fd_sc_hd__decap_3
XFILLER_57_108 VGND VGND VPWR VPWR sky130_fd_sc_hd__decap_3
XFILLER_85_417 VGND VGND VPWR VPWR sky130_fd_sc_hd__decap_3
XFILLER_66_620 VGND VGND VPWR VPWR sky130_fd_sc_hd__decap_3
XFILLER_97_299 VGND VGND VPWR VPWR sky130_fd_sc_hd__decap_3
Xhold1107 _7242_/Q VGND VGND VPWR VPWR _5171_/A sky130_fd_sc_hd__dlygate4sd3_1
Xhold1118 _7186_/Q VGND VGND VPWR VPWR _5286_/A0 sky130_fd_sc_hd__dlygate4sd3_1
Xhold1129 _7195_/Q VGND VGND VPWR VPWR _5270_/A0 sky130_fd_sc_hd__dlygate4sd3_1
X_5022_ _4948_/A _5017_/Y _5020_/X _5021_/X VGND VGND VPWR VPWR _5661_/A sky130_fd_sc_hd__o211a_2
XFILLER_38_388 VGND VGND VPWR VPWR sky130_fd_sc_hd__fill_2
XFILLER_53_314 VGND VGND VPWR VPWR sky130_fd_sc_hd__fill_1
XFILLER_65_152 VGND VGND VPWR VPWR sky130_fd_sc_hd__decap_3
XFILLER_66_675 VGND VGND VPWR VPWR sky130_fd_sc_hd__decap_3
XFILLER_80_100 VGND VGND VPWR VPWR sky130_fd_sc_hd__decap_3
XFILLER_81_623 VGND VGND VPWR VPWR sky130_fd_sc_hd__decap_3
XTAP_TAPCELL_ROW_49_873 VGND VPWR sky130_fd_sc_hd__tapvpwrvgnd_1
XFILLER_19_580 VGND VGND VPWR VPWR sky130_fd_sc_hd__decap_3
XFILLER_65_185 VGND VGND VPWR VPWR sky130_fd_sc_hd__decap_3
XFILLER_80_133 VGND VGND VPWR VPWR sky130_fd_sc_hd__decap_3
XFILLER_81_656 VGND VGND VPWR VPWR sky130_fd_sc_hd__decap_3
X_6973_ clkload6/A _6973_/D VGND VGND VPWR VPWR _6973_/Q sky130_fd_sc_hd__dfxtp_2
XFILLER_22_701 VGND VGND VPWR VPWR sky130_fd_sc_hd__decap_3
XFILLER_34_550 VGND VGND VPWR VPWR sky130_fd_sc_hd__decap_3
XFILLER_80_144 VGND VGND VPWR VPWR sky130_fd_sc_hd__decap_3
XFILLER_110_38 VGND VGND VPWR VPWR sky130_fd_sc_hd__decap_3
XFILLER_21_200 VGND VGND VPWR VPWR sky130_fd_sc_hd__decap_3
XFILLER_61_380 VGND VGND VPWR VPWR sky130_fd_sc_hd__decap_3
XTAP_TAPCELL_ROW_101_1518 VGND VPWR sky130_fd_sc_hd__tapvpwrvgnd_1
X_4806_ _3346_/A _3701_/X _4799_/X _4805_/X VGND VGND VPWR VPWR _4806_/X sky130_fd_sc_hd__a31o_2
XFILLER_119_121 VGND VGND VPWR VPWR sky130_fd_sc_hd__decap_3
XFILLER_21_266 VGND VGND VPWR VPWR sky130_fd_sc_hd__decap_3
XFILLER_21_288 VGND VGND VPWR VPWR sky130_fd_sc_hd__decap_3
X_4737_ _7005_/Q _4775_/A _7006_/Q VGND VGND VPWR VPWR _4738_/B sky130_fd_sc_hd__a21oi_2
XFILLER_107_305 VGND VGND VPWR VPWR sky130_fd_sc_hd__decap_3
XFILLER_119_69 VGND VGND VPWR VPWR sky130_fd_sc_hd__decap_3
X_4668_ _4908_/A _4896_/A VGND VGND VPWR VPWR _4668_/X sky130_fd_sc_hd__and2_2
XFILLER_107_349 VGND VGND VPWR VPWR sky130_fd_sc_hd__decap_3
Xhold930 _6737_/Q VGND VGND VPWR VPWR _6737_/D sky130_fd_sc_hd__dlygate4sd3_1
X_6407_ _6636_/A VGND VGND VPWR VPWR _6407_/Y sky130_fd_sc_hd__inv_2
X_3619_ _3620_/A _3620_/C _4292_/B VGND VGND VPWR VPWR _3619_/Y sky130_fd_sc_hd__o21ai_2
XFILLER_88_200 VGND VGND VPWR VPWR sky130_fd_sc_hd__decap_3
XFILLER_89_712 VGND VGND VPWR VPWR sky130_fd_sc_hd__fill_2
X_7387_ _7387_/CLK _7387_/D _6667_/Y VGND VGND VPWR VPWR _7387_/Q sky130_fd_sc_hd__dfrtp_2
Xhold941 _6806_/Q VGND VGND VPWR VPWR _6806_/D sky130_fd_sc_hd__dlygate4sd3_1
Xhold952 _7056_/Q VGND VGND VPWR VPWR _7056_/D sky130_fd_sc_hd__dlygate4sd3_1
Xhold963 _7113_/Q VGND VGND VPWR VPWR _7113_/D sky130_fd_sc_hd__dlygate4sd3_1
X_4599_ _7281_/Q _5142_/A0 _4599_/S VGND VGND VPWR VPWR _7281_/D sky130_fd_sc_hd__mux2_2
XFILLER_115_382 VGND VGND VPWR VPWR sky130_fd_sc_hd__decap_3
XFILLER_115_393 VGND VGND VPWR VPWR sky130_fd_sc_hd__decap_3
XFILLER_1_638 VGND VGND VPWR VPWR sky130_fd_sc_hd__decap_3
XFILLER_88_233 VGND VGND VPWR VPWR sky130_fd_sc_hd__decap_3
Xhold974 _7105_/Q VGND VGND VPWR VPWR _7105_/D sky130_fd_sc_hd__dlygate4sd3_1
Xhold996 _7112_/Q VGND VGND VPWR VPWR _7112_/D sky130_fd_sc_hd__dlygate4sd3_1
Xhold985 _7107_/Q VGND VGND VPWR VPWR _7107_/D sky130_fd_sc_hd__dlygate4sd3_1
X_6338_ _6463_/A VGND VGND VPWR VPWR _6338_/Y sky130_fd_sc_hd__inv_2
XTAP_TAPCELL_ROW_112_1658 VGND VPWR sky130_fd_sc_hd__tapvpwrvgnd_1
X_6269_ _6678_/A VGND VGND VPWR VPWR _6269_/Y sky130_fd_sc_hd__inv_2
XFILLER_28_22 VGND VGND VPWR VPWR sky130_fd_sc_hd__fill_2
XFILLER_57_620 VGND VGND VPWR VPWR sky130_fd_sc_hd__decap_3
XFILLER_88_277 VGND VGND VPWR VPWR sky130_fd_sc_hd__fill_2
XFILLER_28_44 VGND VGND VPWR VPWR sky130_fd_sc_hd__fill_1
XFILLER_29_322 VGND VGND VPWR VPWR sky130_fd_sc_hd__decap_3
XFILLER_29_355 VGND VGND VPWR VPWR sky130_fd_sc_hd__decap_3
XFILLER_56_130 VGND VGND VPWR VPWR sky130_fd_sc_hd__decap_3
XFILLER_57_653 VGND VGND VPWR VPWR sky130_fd_sc_hd__decap_3
XFILLER_29_388 VGND VGND VPWR VPWR sky130_fd_sc_hd__decap_3
XFILLER_56_141 VGND VGND VPWR VPWR sky130_fd_sc_hd__decap_3
XFILLER_57_697 VGND VGND VPWR VPWR sky130_fd_sc_hd__decap_3
XFILLER_84_450 VGND VGND VPWR VPWR sky130_fd_sc_hd__decap_3
XFILLER_29_399 VGND VGND VPWR VPWR sky130_fd_sc_hd__decap_3
XFILLER_71_111 VGND VGND VPWR VPWR sky130_fd_sc_hd__fill_1
XFILLER_71_133 VGND VGND VPWR VPWR sky130_fd_sc_hd__decap_3
XFILLER_72_634 VGND VGND VPWR VPWR sky130_fd_sc_hd__decap_3
XFILLER_72_645 VGND VGND VPWR VPWR sky130_fd_sc_hd__decap_3
XFILLER_25_561 VGND VGND VPWR VPWR sky130_fd_sc_hd__decap_3
XFILLER_44_358 VGND VGND VPWR VPWR sky130_fd_sc_hd__decap_3
XFILLER_72_678 VGND VGND VPWR VPWR sky130_fd_sc_hd__decap_3
XFILLER_13_712 VGND VGND VPWR VPWR sky130_fd_sc_hd__fill_2
XFILLER_52_380 VGND VGND VPWR VPWR sky130_fd_sc_hd__decap_3
XFILLER_71_199 VGND VGND VPWR VPWR sky130_fd_sc_hd__decap_3
XFILLER_12_222 VGND VGND VPWR VPWR sky130_fd_sc_hd__decap_3
XFILLER_40_542 VGND VGND VPWR VPWR sky130_fd_sc_hd__decap_3
XFILLER_12_266 VGND VGND VPWR VPWR sky130_fd_sc_hd__fill_2
XFILLER_40_586 VGND VGND VPWR VPWR sky130_fd_sc_hd__fill_2
XFILLER_12_299 VGND VGND VPWR VPWR sky130_fd_sc_hd__decap_3
XTAP_TAPCELL_ROW_78_1233 VGND VPWR sky130_fd_sc_hd__tapvpwrvgnd_1
XFILLER_4_421 VGND VGND VPWR VPWR sky130_fd_sc_hd__decap_3
XTAP_TAPCELL_ROW_91_1400 VGND VPWR sky130_fd_sc_hd__tapvpwrvgnd_1
XFILLER_106_371 VGND VGND VPWR VPWR sky130_fd_sc_hd__decap_3
XFILLER_4_498 VGND VGND VPWR VPWR sky130_fd_sc_hd__decap_3
XFILLER_79_222 VGND VGND VPWR VPWR sky130_fd_sc_hd__fill_2
XFILLER_79_255 VGND VGND VPWR VPWR sky130_fd_sc_hd__decap_3
XFILLER_48_620 VGND VGND VPWR VPWR sky130_fd_sc_hd__decap_3
XFILLER_67_417 VGND VGND VPWR VPWR sky130_fd_sc_hd__decap_3
XFILLER_79_277 VGND VGND VPWR VPWR sky130_fd_sc_hd__decap_3
XFILLER_94_203 VGND VGND VPWR VPWR sky130_fd_sc_hd__decap_3
XFILLER_94_247 VGND VGND VPWR VPWR sky130_fd_sc_hd__decap_3
XFILLER_94_269 VGND VGND VPWR VPWR sky130_fd_sc_hd__decap_3
XPHY_EDGE_ROW_13_Right_13 VGND VGND VPWR VPWR sky130_fd_sc_hd__decap_3
XFILLER_48_675 VGND VGND VPWR VPWR sky130_fd_sc_hd__decap_3
XFILLER_63_623 VGND VGND VPWR VPWR sky130_fd_sc_hd__decap_3
XFILLER_85_72 VGND VGND VPWR VPWR sky130_fd_sc_hd__decap_3
XTAP_TAPCELL_ROW_89_1373 VGND VPWR sky130_fd_sc_hd__tapvpwrvgnd_1
XFILLER_35_325 VGND VGND VPWR VPWR sky130_fd_sc_hd__decap_3
XFILLER_47_196 VGND VGND VPWR VPWR sky130_fd_sc_hd__decap_3
XFILLER_62_111 VGND VGND VPWR VPWR sky130_fd_sc_hd__decap_3
XFILLER_63_656 VGND VGND VPWR VPWR sky130_fd_sc_hd__decap_3
XTAP_TAPCELL_ROW_46_832 VGND VPWR sky130_fd_sc_hd__tapvpwrvgnd_1
XFILLER_62_144 VGND VGND VPWR VPWR sky130_fd_sc_hd__decap_3
XFILLER_90_464 VGND VGND VPWR VPWR sky130_fd_sc_hd__decap_3
X_3970_ _7355_/Q _4513_/A0 _3996_/S VGND VGND VPWR VPWR _7355_/D sky130_fd_sc_hd__mux2_2
XFILLER_31_531 VGND VGND VPWR VPWR sky130_fd_sc_hd__fill_1
XFILLER_31_553 VGND VGND VPWR VPWR sky130_fd_sc_hd__decap_3
XFILLER_31_586 VGND VGND VPWR VPWR sky130_fd_sc_hd__decap_3
XFILLER_86_3 VGND VGND VPWR VPWR sky130_fd_sc_hd__decap_3
X_5640_ _5642_/A _5640_/B VGND VGND VPWR VPWR _5640_/Y sky130_fd_sc_hd__nor2_2
XFILLER_117_603 VGND VGND VPWR VPWR sky130_fd_sc_hd__decap_3
X_5571_ _5571_/A1 _4960_/A _4944_/C VGND VGND VPWR VPWR _7046_/D sky130_fd_sc_hd__a21o_2
XPHY_EDGE_ROW_22_Right_22 VGND VGND VPWR VPWR sky130_fd_sc_hd__decap_3
X_7310_ _7342_/CLK _7310_/D _6590_/Y VGND VGND VPWR VPWR _7310_/Q sky130_fd_sc_hd__dfrtp_2
X_4522_ _4522_/A0 _7286_/Q _4528_/B VGND VGND VPWR VPWR _7318_/D sky130_fd_sc_hd__mux2_2
XFILLER_117_647 VGND VGND VPWR VPWR sky130_fd_sc_hd__decap_3
XFILLER_7_281 VGND VGND VPWR VPWR sky130_fd_sc_hd__decap_3
X_7241_ _7402_/CLK _7241_/D _6521_/Y VGND VGND VPWR VPWR _7241_/Q sky130_fd_sc_hd__dfrtp_2
X_4453_ _4453_/A VGND VGND VPWR VPWR _4762_/B sky130_fd_sc_hd__inv_2
XFILLER_116_168 VGND VGND VPWR VPWR sky130_fd_sc_hd__decap_3
XFILLER_98_531 VGND VGND VPWR VPWR sky130_fd_sc_hd__fill_1
XFILLER_98_542 VGND VGND VPWR VPWR sky130_fd_sc_hd__decap_3
X_7172_ _7362_/CLK _7172_/D _6452_/Y VGND VGND VPWR VPWR _7172_/Q sky130_fd_sc_hd__dfrtp_2
X_4384_ _4384_/A _4968_/A _4384_/C VGND VGND VPWR VPWR _4778_/B sky130_fd_sc_hd__nand3_2
XFILLER_112_352 VGND VGND VPWR VPWR sky130_fd_sc_hd__decap_3
XFILLER_86_704 VGND VGND VPWR VPWR sky130_fd_sc_hd__decap_3
XFILLER_98_575 VGND VGND VPWR VPWR sky130_fd_sc_hd__fill_1
X_3335_ _3319_/X _5238_/B _3329_/Y _3339_/C1 VGND VGND VPWR VPWR _3442_/A sky130_fd_sc_hd__a211o_2
XFILLER_100_503 VGND VGND VPWR VPWR sky130_fd_sc_hd__fill_2
XFILLER_100_536 VGND VGND VPWR VPWR sky130_fd_sc_hd__fill_2
XFILLER_112_374 VGND VGND VPWR VPWR sky130_fd_sc_hd__decap_3
XFILLER_39_620 VGND VGND VPWR VPWR sky130_fd_sc_hd__decap_3
XFILLER_58_439 VGND VGND VPWR VPWR sky130_fd_sc_hd__fill_1
XFILLER_85_225 VGND VGND VPWR VPWR sky130_fd_sc_hd__decap_3
XPHY_EDGE_ROW_31_Right_31 VGND VGND VPWR VPWR sky130_fd_sc_hd__decap_3
XFILLER_38_130 VGND VGND VPWR VPWR sky130_fd_sc_hd__decap_3
XFILLER_39_653 VGND VGND VPWR VPWR sky130_fd_sc_hd__decap_3
X_5005_ _5004_/A _5004_/B _4814_/A VGND VGND VPWR VPWR _5005_/Y sky130_fd_sc_hd__a21oi_2
XFILLER_38_141 VGND VGND VPWR VPWR sky130_fd_sc_hd__decap_3
XFILLER_54_612 VGND VGND VPWR VPWR sky130_fd_sc_hd__decap_3
XFILLER_66_461 VGND VGND VPWR VPWR sky130_fd_sc_hd__decap_3
XFILLER_26_347 VGND VGND VPWR VPWR sky130_fd_sc_hd__decap_3
XFILLER_38_185 VGND VGND VPWR VPWR sky130_fd_sc_hd__decap_3
XFILLER_39_697 VGND VGND VPWR VPWR sky130_fd_sc_hd__decap_3
XFILLER_54_645 VGND VGND VPWR VPWR sky130_fd_sc_hd__decap_3
XFILLER_53_133 VGND VGND VPWR VPWR sky130_fd_sc_hd__fill_1
XFILLER_54_678 VGND VGND VPWR VPWR sky130_fd_sc_hd__decap_3
XFILLER_81_475 VGND VGND VPWR VPWR sky130_fd_sc_hd__decap_3
X_6956_ _6968_/CLK _6956_/D VGND VGND VPWR VPWR _6956_/Q sky130_fd_sc_hd__dfxtp_2
XFILLER_22_520 VGND VGND VPWR VPWR sky130_fd_sc_hd__decap_3
XFILLER_41_317 VGND VGND VPWR VPWR sky130_fd_sc_hd__decap_3
XFILLER_53_188 VGND VGND VPWR VPWR sky130_fd_sc_hd__decap_3
X_6887_ _6943_/CLK _6887_/D VGND VGND VPWR VPWR _6887_/Q sky130_fd_sc_hd__dfxtp_2
XTAP_TAPCELL_ROW_62_1034 VGND VPWR sky130_fd_sc_hd__tapvpwrvgnd_1
XTAP_TAPCELL_ROW_24_559 VGND VPWR sky130_fd_sc_hd__tapvpwrvgnd_1
XFILLER_10_704 VGND VGND VPWR VPWR sky130_fd_sc_hd__decap_3
XPHY_EDGE_ROW_40_Right_40 VGND VGND VPWR VPWR sky130_fd_sc_hd__decap_3
XFILLER_14_79 VGND VGND VPWR VPWR sky130_fd_sc_hd__decap_3
XFILLER_107_102 VGND VGND VPWR VPWR sky130_fd_sc_hd__fill_1
XFILLER_108_625 VGND VGND VPWR VPWR sky130_fd_sc_hd__decap_3
XFILLER_107_113 VGND VGND VPWR VPWR sky130_fd_sc_hd__decap_3
XFILLER_108_669 VGND VGND VPWR VPWR sky130_fd_sc_hd__decap_3
XPHY_EDGE_ROW_15_Left_135 VGND VGND VPWR VPWR sky130_fd_sc_hd__decap_3
XFILLER_1_435 VGND VGND VPWR VPWR sky130_fd_sc_hd__fill_2
XFILLER_89_520 VGND VGND VPWR VPWR sky130_fd_sc_hd__fill_2
Xhold760 _6841_/Q VGND VGND VPWR VPWR _6841_/D sky130_fd_sc_hd__dlygate4sd3_1
Xhold771 _6739_/Q VGND VGND VPWR VPWR _6739_/D sky130_fd_sc_hd__dlygate4sd3_1
Xhold782 _6778_/Q VGND VGND VPWR VPWR _6778_/D sky130_fd_sc_hd__dlygate4sd3_1
XFILLER_103_330 VGND VGND VPWR VPWR sky130_fd_sc_hd__decap_3
XFILLER_1_457 VGND VGND VPWR VPWR sky130_fd_sc_hd__decap_3
XFILLER_89_564 VGND VGND VPWR VPWR sky130_fd_sc_hd__decap_3
Xhold793 _6733_/Q VGND VGND VPWR VPWR _6733_/D sky130_fd_sc_hd__dlygate4sd3_1
XTAP_TAPCELL_ROW_73_1174 VGND VPWR sky130_fd_sc_hd__tapvpwrvgnd_1
XFILLER_103_374 VGND VGND VPWR VPWR sky130_fd_sc_hd__decap_3
XFILLER_76_225 VGND VGND VPWR VPWR sky130_fd_sc_hd__decap_3
XFILLER_103_396 VGND VGND VPWR VPWR sky130_fd_sc_hd__decap_3
XFILLER_92_707 VGND VGND VPWR VPWR sky130_fd_sc_hd__decap_3
XPHY_EDGE_ROW_24_Left_144 VGND VGND VPWR VPWR sky130_fd_sc_hd__decap_3
XFILLER_29_196 VGND VGND VPWR VPWR sky130_fd_sc_hd__decap_3
XFILLER_45_623 VGND VGND VPWR VPWR sky130_fd_sc_hd__decap_3
XFILLER_91_228 VGND VGND VPWR VPWR sky130_fd_sc_hd__decap_3
XFILLER_91_239 VGND VGND VPWR VPWR sky130_fd_sc_hd__decap_3
XFILLER_45_656 VGND VGND VPWR VPWR sky130_fd_sc_hd__decap_3
XFILLER_60_637 VGND VGND VPWR VPWR sky130_fd_sc_hd__decap_3
XFILLER_60_648 VGND VGND VPWR VPWR sky130_fd_sc_hd__decap_3
XFILLER_72_475 VGND VGND VPWR VPWR sky130_fd_sc_hd__fill_1
XFILLER_111_81 VGND VGND VPWR VPWR sky130_fd_sc_hd__decap_3
XFILLER_71_30 VGND VGND VPWR VPWR sky130_fd_sc_hd__decap_3
XFILLER_13_564 VGND VGND VPWR VPWR sky130_fd_sc_hd__decap_3
XFILLER_71_74 VGND VGND VPWR VPWR sky130_fd_sc_hd__decap_3
XFILLER_9_524 VGND VGND VPWR VPWR sky130_fd_sc_hd__decap_3
XFILLER_13_597 VGND VGND VPWR VPWR sky130_fd_sc_hd__decap_3
XFILLER_71_96 VGND VGND VPWR VPWR sky130_fd_sc_hd__decap_3
XFILLER_72_9 VGND VGND VPWR VPWR sky130_fd_sc_hd__decap_3
XTAP_TAPCELL_ROW_51_890 VGND VPWR sky130_fd_sc_hd__tapvpwrvgnd_1
XFILLER_9_557 VGND VGND VPWR VPWR sky130_fd_sc_hd__decap_3
XPHY_EDGE_ROW_33_Left_153 VGND VGND VPWR VPWR sky130_fd_sc_hd__decap_3
XFILLER_9_579 VGND VGND VPWR VPWR sky130_fd_sc_hd__decap_3
XFILLER_114_628 VGND VGND VPWR VPWR sky130_fd_sc_hd__decap_3
XFILLER_107_691 VGND VGND VPWR VPWR sky130_fd_sc_hd__decap_3
XFILLER_113_116 VGND VGND VPWR VPWR sky130_fd_sc_hd__decap_3
XFILLER_113_138 VGND VGND VPWR VPWR sky130_fd_sc_hd__decap_3
XFILLER_4_262 VGND VGND VPWR VPWR sky130_fd_sc_hd__decap_3
XFILLER_68_704 VGND VGND VPWR VPWR sky130_fd_sc_hd__decap_3
XFILLER_67_225 VGND VGND VPWR VPWR sky130_fd_sc_hd__decap_3
XFILLER_95_523 VGND VGND VPWR VPWR sky130_fd_sc_hd__decap_3
XFILLER_96_60 VGND VGND VPWR VPWR sky130_fd_sc_hd__decap_3
XPHY_EDGE_ROW_42_Left_162 VGND VGND VPWR VPWR sky130_fd_sc_hd__decap_3
XFILLER_36_601 VGND VGND VPWR VPWR sky130_fd_sc_hd__decap_3
XFILLER_55_409 VGND VGND VPWR VPWR sky130_fd_sc_hd__fill_1
XFILLER_82_206 VGND VGND VPWR VPWR sky130_fd_sc_hd__decap_3
XFILLER_35_122 VGND VGND VPWR VPWR sky130_fd_sc_hd__decap_3
XFILLER_36_634 VGND VGND VPWR VPWR sky130_fd_sc_hd__decap_3
XFILLER_36_645 VGND VGND VPWR VPWR sky130_fd_sc_hd__decap_3
XFILLER_63_431 VGND VGND VPWR VPWR sky130_fd_sc_hd__decap_3
XFILLER_75_291 VGND VGND VPWR VPWR sky130_fd_sc_hd__decap_3
XFILLER_82_228 VGND VGND VPWR VPWR sky130_fd_sc_hd__fill_1
XTAP_TAPCELL_ROW_59_990 VGND VPWR sky130_fd_sc_hd__tapvpwrvgnd_1
XFILLER_36_678 VGND VGND VPWR VPWR sky130_fd_sc_hd__decap_3
Xplace431 _3469_/A VGND VGND VPWR VPWR _3991_/A sky130_fd_sc_hd__buf_2
Xplace420 _4305_/B VGND VGND VPWR VPWR _4265_/B sky130_fd_sc_hd__buf_2
X_6810_ clkload4/A _6810_/D VGND VGND VPWR VPWR _6810_/Q sky130_fd_sc_hd__dfxtp_2
XFILLER_23_306 VGND VGND VPWR VPWR sky130_fd_sc_hd__decap_3
XFILLER_35_166 VGND VGND VPWR VPWR sky130_fd_sc_hd__fill_2
XFILLER_51_615 VGND VGND VPWR VPWR sky130_fd_sc_hd__fill_1
XFILLER_51_626 VGND VGND VPWR VPWR sky130_fd_sc_hd__decap_3
XFILLER_90_283 VGND VGND VPWR VPWR sky130_fd_sc_hd__decap_3
Xplace464 _4261_/A2 VGND VGND VPWR VPWR _4354_/B1 sky130_fd_sc_hd__buf_2
Xplace453 _4517_/S VGND VGND VPWR VPWR _4497_/S sky130_fd_sc_hd__buf_2
Xplace442 _4690_/B VGND VGND VPWR VPWR _5633_/B sky130_fd_sc_hd__buf_2
XFILLER_35_199 VGND VGND VPWR VPWR sky130_fd_sc_hd__decap_3
XFILLER_51_659 VGND VGND VPWR VPWR sky130_fd_sc_hd__decap_3
Xplace486 _3366_/X VGND VGND VPWR VPWR _4421_/B1 sky130_fd_sc_hd__buf_2
Xplace497 _5647_/A VGND VGND VPWR VPWR _5587_/B sky130_fd_sc_hd__buf_2
Xplace475 _3966_/S VGND VGND VPWR VPWR _3964_/S sky130_fd_sc_hd__buf_2
X_6741_ _6906_/CLK _6741_/D VGND VGND VPWR VPWR _6741_/Q sky130_fd_sc_hd__dfxtp_2
X_6672_ _6672_/A VGND VGND VPWR VPWR _6672_/Y sky130_fd_sc_hd__inv_2
X_3884_ _6824_/Q _3921_/A2 _5660_/B _6809_/Q _3883_/X VGND VGND VPWR VPWR _3884_/X
+ sky130_fd_sc_hd__a221o_2
XTAP_TAPCELL_ROW_21_518 VGND VPWR sky130_fd_sc_hd__tapvpwrvgnd_1
XFILLER_31_372 VGND VGND VPWR VPWR sky130_fd_sc_hd__decap_3
XPHY_EDGE_ROW_51_Left_171 VGND VGND VPWR VPWR sky130_fd_sc_hd__decap_3
XFILLER_117_422 VGND VGND VPWR VPWR sky130_fd_sc_hd__fill_2
XFILLER_105_606 VGND VGND VPWR VPWR sky130_fd_sc_hd__decap_3
XFILLER_105_617 VGND VGND VPWR VPWR sky130_fd_sc_hd__decap_3
X_4505_ _4505_/A0 _7295_/Q _4517_/S VGND VGND VPWR VPWR _7327_/D sky130_fd_sc_hd__mux2_2
XFILLER_104_116 VGND VGND VPWR VPWR sky130_fd_sc_hd__decap_3
XFILLER_116_15 VGND VGND VPWR VPWR sky130_fd_sc_hd__decap_3
X_7224_ _7355_/CLK _7224_/D _6504_/Y VGND VGND VPWR VPWR _7224_/Q sky130_fd_sc_hd__dfrtp_2
X_4436_ _7303_/Q _4914_/S _4436_/B1 _7175_/Q _4435_/X VGND VGND VPWR VPWR _4436_/X
+ sky130_fd_sc_hd__a221o_2
XFILLER_113_650 VGND VGND VPWR VPWR sky130_fd_sc_hd__decap_3
X_7155_ _7345_/CLK _7155_/D _6435_/Y VGND VGND VPWR VPWR _7155_/Q sky130_fd_sc_hd__dfrtp_2
X_4367_ _4367_/A _4367_/B _4367_/C VGND VGND VPWR VPWR _5054_/A sky130_fd_sc_hd__and3_2
XFILLER_112_160 VGND VGND VPWR VPWR sky130_fd_sc_hd__decap_3
XFILLER_113_694 VGND VGND VPWR VPWR sky130_fd_sc_hd__decap_3
XFILLER_116_59 VGND VGND VPWR VPWR sky130_fd_sc_hd__decap_3
XFILLER_58_203 VGND VGND VPWR VPWR sky130_fd_sc_hd__decap_3
XFILLER_86_512 VGND VGND VPWR VPWR sky130_fd_sc_hd__decap_3
X_3318_ _6979_/Q _3318_/B VGND VGND VPWR VPWR _5647_/B sky130_fd_sc_hd__nand2_2
XPHY_EDGE_ROW_60_Left_180 VGND VGND VPWR VPWR sky130_fd_sc_hd__decap_3
XFILLER_100_333 VGND VGND VPWR VPWR sky130_fd_sc_hd__decap_3
XFILLER_58_236 VGND VGND VPWR VPWR sky130_fd_sc_hd__decap_3
XFILLER_74_707 VGND VGND VPWR VPWR sky130_fd_sc_hd__decap_3
XFILLER_86_545 VGND VGND VPWR VPWR sky130_fd_sc_hd__fill_2
X_7086_ _7086_/CLK _7086_/D _6366_/Y VGND VGND VPWR VPWR _7086_/Q sky130_fd_sc_hd__dfrtp_2
X_4298_ _3620_/C _4292_/X _4293_/X _4297_/Y VGND VGND VPWR VPWR _4298_/X sky130_fd_sc_hd__a211o_2
XFILLER_27_612 VGND VGND VPWR VPWR sky130_fd_sc_hd__decap_3
XTAP_TAPCELL_ROW_29_618 VGND VPWR sky130_fd_sc_hd__tapvpwrvgnd_1
XFILLER_26_100 VGND VGND VPWR VPWR sky130_fd_sc_hd__decap_3
XFILLER_27_623 VGND VGND VPWR VPWR sky130_fd_sc_hd__decap_3
XFILLER_73_228 VGND VGND VPWR VPWR sky130_fd_sc_hd__decap_3
XFILLER_27_656 VGND VGND VPWR VPWR sky130_fd_sc_hd__decap_3
XFILLER_66_291 VGND VGND VPWR VPWR sky130_fd_sc_hd__fill_1
XFILLER_92_29 VGND VGND VPWR VPWR sky130_fd_sc_hd__decap_3
XTAP_TAPCELL_ROW_1_276 VGND VPWR sky130_fd_sc_hd__tapvpwrvgnd_1
XTAP_TAPCELL_ROW_1_265 VGND VPWR sky130_fd_sc_hd__tapvpwrvgnd_1
XFILLER_42_615 VGND VGND VPWR VPWR sky130_fd_sc_hd__decap_3
XFILLER_25_78 VGND VGND VPWR VPWR sky130_fd_sc_hd__decap_3
XFILLER_41_125 VGND VGND VPWR VPWR sky130_fd_sc_hd__fill_2
XFILLER_42_648 VGND VGND VPWR VPWR sky130_fd_sc_hd__decap_3
X_6939_ _6941_/CLK _6939_/D VGND VGND VPWR VPWR _6939_/Q sky130_fd_sc_hd__dfxtp_2
XFILLER_22_361 VGND VGND VPWR VPWR sky130_fd_sc_hd__decap_3
XFILLER_22_383 VGND VGND VPWR VPWR sky130_fd_sc_hd__fill_1
XFILLER_50_681 VGND VGND VPWR VPWR sky130_fd_sc_hd__decap_3
XFILLER_10_545 VGND VGND VPWR VPWR sky130_fd_sc_hd__decap_3
XFILLER_10_578 VGND VGND VPWR VPWR sky130_fd_sc_hd__decap_3
XFILLER_6_505 VGND VGND VPWR VPWR sky130_fd_sc_hd__fill_1
XFILLER_10_589 VGND VGND VPWR VPWR sky130_fd_sc_hd__decap_3
XFILLER_108_466 VGND VGND VPWR VPWR sky130_fd_sc_hd__decap_3
XFILLER_108_477 VGND VGND VPWR VPWR sky130_fd_sc_hd__decap_3
XFILLER_108_499 VGND VGND VPWR VPWR sky130_fd_sc_hd__decap_3
XFILLER_111_609 VGND VGND VPWR VPWR sky130_fd_sc_hd__decap_3
XFILLER_96_309 VGND VGND VPWR VPWR sky130_fd_sc_hd__fill_2
XTAP_TAPCELL_ROW_9_376 VGND VPWR sky130_fd_sc_hd__tapvpwrvgnd_1
XTAP_TAPCELL_ROW_9_365 VGND VPWR sky130_fd_sc_hd__tapvpwrvgnd_1
XFILLER_104_672 VGND VGND VPWR VPWR sky130_fd_sc_hd__decap_3
XFILLER_1_265 VGND VGND VPWR VPWR sky130_fd_sc_hd__decap_3
XFILLER_77_523 VGND VGND VPWR VPWR sky130_fd_sc_hd__fill_2
XFILLER_89_372 VGND VGND VPWR VPWR sky130_fd_sc_hd__decap_3
XFILLER_1_287 VGND VGND VPWR VPWR sky130_fd_sc_hd__decap_3
XFILLER_49_225 VGND VGND VPWR VPWR sky130_fd_sc_hd__decap_3
XFILLER_18_601 VGND VGND VPWR VPWR sky130_fd_sc_hd__decap_3
XFILLER_49_269 VGND VGND VPWR VPWR sky130_fd_sc_hd__fill_1
XFILLER_92_504 VGND VGND VPWR VPWR sky130_fd_sc_hd__decap_3
XFILLER_18_634 VGND VGND VPWR VPWR sky130_fd_sc_hd__decap_3
XFILLER_18_645 VGND VGND VPWR VPWR sky130_fd_sc_hd__decap_3
XFILLER_66_85 VGND VGND VPWR VPWR sky130_fd_sc_hd__decap_3
XFILLER_18_678 VGND VGND VPWR VPWR sky130_fd_sc_hd__decap_3
Xhold1290 _7296_/Q VGND VGND VPWR VPWR _4569_/A sky130_fd_sc_hd__dlygate4sd3_1
XTAP_TAPCELL_ROW_86_1332 VGND VPWR sky130_fd_sc_hd__tapvpwrvgnd_1
XTAP_TAPCELL_ROW_56_960 VGND VPWR sky130_fd_sc_hd__tapvpwrvgnd_1
XFILLER_17_166 VGND VGND VPWR VPWR sky130_fd_sc_hd__fill_2
XFILLER_33_615 VGND VGND VPWR VPWR sky130_fd_sc_hd__fill_1
XFILLER_33_626 VGND VGND VPWR VPWR sky130_fd_sc_hd__decap_3
XFILLER_45_475 VGND VGND VPWR VPWR sky130_fd_sc_hd__fill_1
XFILLER_72_261 VGND VGND VPWR VPWR sky130_fd_sc_hd__decap_3
XFILLER_32_125 VGND VGND VPWR VPWR sky130_fd_sc_hd__decap_3
XFILLER_33_659 VGND VGND VPWR VPWR sky130_fd_sc_hd__decap_3
XFILLER_60_456 VGND VGND VPWR VPWR sky130_fd_sc_hd__decap_3
XFILLER_82_73 VGND VGND VPWR VPWR sky130_fd_sc_hd__decap_3
XFILLER_13_361 VGND VGND VPWR VPWR sky130_fd_sc_hd__decap_3
XFILLER_20_309 VGND VGND VPWR VPWR sky130_fd_sc_hd__fill_2
XFILLER_32_169 VGND VGND VPWR VPWR sky130_fd_sc_hd__decap_3
XFILLER_13_383 VGND VGND VPWR VPWR sky130_fd_sc_hd__fill_1
XFILLER_9_332 VGND VGND VPWR VPWR sky130_fd_sc_hd__decap_3
XFILLER_9_354 VGND VGND VPWR VPWR sky130_fd_sc_hd__decap_3
XTAP_TAPCELL_ROW_97_1472 VGND VPWR sky130_fd_sc_hd__tapvpwrvgnd_1
XFILLER_5_582 VGND VGND VPWR VPWR sky130_fd_sc_hd__decap_3
X_5270_ _5270_/A0 _5040_/X _5292_/S VGND VGND VPWR VPWR _7195_/D sky130_fd_sc_hd__mux2_2
XFILLER_99_125 VGND VGND VPWR VPWR sky130_fd_sc_hd__decap_3
XFILLER_114_458 VGND VGND VPWR VPWR sky130_fd_sc_hd__decap_3
X_4221_ _7228_/Q _4353_/A2 _4269_/B1 _7041_/Q _4220_/X VGND VGND VPWR VPWR _4221_/X
+ sky130_fd_sc_hd__a221o_2
XFILLER_99_169 VGND VGND VPWR VPWR sky130_fd_sc_hd__decap_3
XFILLER_110_631 VGND VGND VPWR VPWR sky130_fd_sc_hd__decap_3
XFILLER_68_545 VGND VGND VPWR VPWR sky130_fd_sc_hd__fill_1
XFILLER_95_320 VGND VGND VPWR VPWR sky130_fd_sc_hd__decap_3
X_4152_ _7106_/Q _4417_/B1 _4351_/B1 _7138_/Q VGND VGND VPWR VPWR _4152_/X sky130_fd_sc_hd__a22o_2
XFILLER_110_675 VGND VGND VPWR VPWR sky130_fd_sc_hd__decap_3
XFILLER_55_206 VGND VGND VPWR VPWR sky130_fd_sc_hd__decap_3
XFILLER_56_707 VGND VGND VPWR VPWR sky130_fd_sc_hd__decap_3
XFILLER_68_589 VGND VGND VPWR VPWR sky130_fd_sc_hd__fill_1
XFILLER_95_353 VGND VGND VPWR VPWR sky130_fd_sc_hd__decap_3
X_4083_ _7366_/Q _4419_/B1 _4459_/C1 _7174_/Q VGND VGND VPWR VPWR _4083_/X sky130_fd_sc_hd__a22o_2
XFILLER_48_280 VGND VGND VPWR VPWR sky130_fd_sc_hd__decap_3
XFILLER_55_228 VGND VGND VPWR VPWR sky130_fd_sc_hd__decap_3
XFILLER_95_386 VGND VGND VPWR VPWR sky130_fd_sc_hd__decap_3
XFILLER_24_604 VGND VGND VPWR VPWR sky130_fd_sc_hd__decap_3
XFILLER_24_637 VGND VGND VPWR VPWR sky130_fd_sc_hd__decap_3
XFILLER_36_475 VGND VGND VPWR VPWR sky130_fd_sc_hd__fill_1
XFILLER_91_570 VGND VGND VPWR VPWR sky130_fd_sc_hd__decap_3
XFILLER_24_648 VGND VGND VPWR VPWR sky130_fd_sc_hd__decap_3
XFILLER_51_445 VGND VGND VPWR VPWR sky130_fd_sc_hd__decap_3
XFILLER_63_294 VGND VGND VPWR VPWR sky130_fd_sc_hd__fill_2
X_4985_ _4620_/A _5032_/A _5031_/B _4630_/X VGND VGND VPWR VPWR _5003_/B sky130_fd_sc_hd__a31o_2
X_6724_ clkload3/A _6724_/D VGND VGND VPWR VPWR _6724_/Q sky130_fd_sc_hd__dfxtp_2
XFILLER_32_681 VGND VGND VPWR VPWR sky130_fd_sc_hd__decap_3
XTAP_TAPCELL_ROW_34_687 VGND VPWR sky130_fd_sc_hd__tapvpwrvgnd_1
X_6655_ _6662_/A VGND VGND VPWR VPWR _6655_/Y sky130_fd_sc_hd__inv_2
X_3867_ _3629_/Y _3866_/X _4770_/A1 VGND VGND VPWR VPWR _3867_/X sky130_fd_sc_hd__o21a_2
X_6586_ _6622_/A VGND VGND VPWR VPWR _6586_/Y sky130_fd_sc_hd__inv_2
X_3798_ _6738_/Q _3879_/B1 _3665_/X _6744_/Q _3797_/X VGND VGND VPWR VPWR _3798_/X
+ sky130_fd_sc_hd__a221o_2
XFILLER_3_508 VGND VGND VPWR VPWR sky130_fd_sc_hd__decap_3
XFILLER_105_458 VGND VGND VPWR VPWR sky130_fd_sc_hd__decap_3
XFILLER_78_309 VGND VGND VPWR VPWR sky130_fd_sc_hd__decap_3
X_7207_ _7406_/CLK _7207_/D _6487_/Y VGND VGND VPWR VPWR _7207_/Q sky130_fd_sc_hd__dfrtp_2
Xoutput662 _6986_/Q VGND VGND VPWR VPWR pc_out[9] sky130_fd_sc_hd__clkdlybuf4s25_1
Xoutput651 _7005_/Q VGND VGND VPWR VPWR pc_out[28] sky130_fd_sc_hd__clkdlybuf4s25_1
Xoutput640 _6995_/Q VGND VGND VPWR VPWR pc_out[18] sky130_fd_sc_hd__clkdlybuf4s25_1
X_4419_ _7304_/Q _4419_/A2 _4419_/B1 _7368_/Q _4429_/C1 VGND VGND VPWR VPWR _4419_/X
+ sky130_fd_sc_hd__a221o_2
XTAP_TAPCELL_ROW_6_335 VGND VPWR sky130_fd_sc_hd__tapvpwrvgnd_1
XFILLER_101_620 VGND VGND VPWR VPWR sky130_fd_sc_hd__decap_3
XFILLER_59_523 VGND VGND VPWR VPWR sky130_fd_sc_hd__decap_3
XFILLER_86_320 VGND VGND VPWR VPWR sky130_fd_sc_hd__decap_3
X_7138_ _7370_/CLK _7138_/D _6418_/Y VGND VGND VPWR VPWR _7138_/Q sky130_fd_sc_hd__dfrtp_2
XTAP_TAPCELL_ROW_70_1133 VGND VPWR sky130_fd_sc_hd__tapvpwrvgnd_1
XFILLER_100_141 VGND VGND VPWR VPWR sky130_fd_sc_hd__decap_3
XFILLER_101_653 VGND VGND VPWR VPWR sky130_fd_sc_hd__decap_3
XFILLER_46_206 VGND VGND VPWR VPWR sky130_fd_sc_hd__decap_3
XFILLER_86_375 VGND VGND VPWR VPWR sky130_fd_sc_hd__decap_3
X_7069_ _7390_/CLK _7069_/D _6349_/Y VGND VGND VPWR VPWR _7069_/Q sky130_fd_sc_hd__dfrtp_2
XTAP_TAPCELL_ROW_109_1619 VGND VPWR sky130_fd_sc_hd__tapvpwrvgnd_1
XFILLER_100_174 VGND VGND VPWR VPWR sky130_fd_sc_hd__decap_3
XFILLER_101_697 VGND VGND VPWR VPWR sky130_fd_sc_hd__decap_3
XFILLER_46_239 VGND VGND VPWR VPWR sky130_fd_sc_hd__decap_3
XFILLER_14_103 VGND VGND VPWR VPWR sky130_fd_sc_hd__decap_3
XFILLER_15_626 VGND VGND VPWR VPWR sky130_fd_sc_hd__decap_3
XFILLER_27_464 VGND VGND VPWR VPWR sky130_fd_sc_hd__decap_3
XFILLER_54_250 VGND VGND VPWR VPWR sky130_fd_sc_hd__fill_2
XFILLER_70_710 VGND VGND VPWR VPWR sky130_fd_sc_hd__decap_3
XFILLER_15_659 VGND VGND VPWR VPWR sky130_fd_sc_hd__decap_3
XFILLER_14_147 VGND VGND VPWR VPWR sky130_fd_sc_hd__decap_3
XFILLER_30_607 VGND VGND VPWR VPWR sky130_fd_sc_hd__decap_3
XTAP_TAPCELL_ROW_81_1273 VGND VPWR sky130_fd_sc_hd__tapvpwrvgnd_1
XFILLER_10_331 VGND VGND VPWR VPWR sky130_fd_sc_hd__decap_3
XFILLER_22_180 VGND VGND VPWR VPWR sky130_fd_sc_hd__fill_2
XFILLER_6_324 VGND VGND VPWR VPWR sky130_fd_sc_hd__decap_3
XFILLER_108_230 VGND VGND VPWR VPWR sky130_fd_sc_hd__fill_1
XFILLER_6_368 VGND VGND VPWR VPWR sky130_fd_sc_hd__fill_2
XFILLER_2_563 VGND VGND VPWR VPWR sky130_fd_sc_hd__decap_3
XFILLER_97_629 VGND VGND VPWR VPWR sky130_fd_sc_hd__decap_3
XFILLER_104_480 VGND VGND VPWR VPWR sky130_fd_sc_hd__decap_3
XFILLER_77_73 VGND VGND VPWR VPWR sky130_fd_sc_hd__decap_3
XFILLER_96_128 VGND VGND VPWR VPWR sky130_fd_sc_hd__decap_3
XFILLER_37_206 VGND VGND VPWR VPWR sky130_fd_sc_hd__decap_3
XFILLER_38_707 VGND VGND VPWR VPWR sky130_fd_sc_hd__decap_3
XFILLER_77_364 VGND VGND VPWR VPWR sky130_fd_sc_hd__decap_3
XFILLER_37_239 VGND VGND VPWR VPWR sky130_fd_sc_hd__decap_3
XFILLER_65_526 VGND VGND VPWR VPWR sky130_fd_sc_hd__fill_1
XFILLER_65_548 VGND VGND VPWR VPWR sky130_fd_sc_hd__decap_3
XFILLER_92_312 VGND VGND VPWR VPWR sky130_fd_sc_hd__decap_3
XFILLER_18_453 VGND VGND VPWR VPWR sky130_fd_sc_hd__decap_3
XFILLER_80_507 VGND VGND VPWR VPWR sky130_fd_sc_hd__decap_3
XFILLER_45_250 VGND VGND VPWR VPWR sky130_fd_sc_hd__fill_2
XFILLER_93_72 VGND VGND VPWR VPWR sky130_fd_sc_hd__decap_3
XFILLER_33_434 VGND VGND VPWR VPWR sky130_fd_sc_hd__decap_3
XFILLER_45_294 VGND VGND VPWR VPWR sky130_fd_sc_hd__decap_3
XFILLER_21_629 VGND VGND VPWR VPWR sky130_fd_sc_hd__decap_3
XFILLER_60_253 VGND VGND VPWR VPWR sky130_fd_sc_hd__decap_3
XFILLER_14_681 VGND VGND VPWR VPWR sky130_fd_sc_hd__decap_3
XFILLER_20_117 VGND VGND VPWR VPWR sky130_fd_sc_hd__decap_3
XFILLER_33_489 VGND VGND VPWR VPWR sky130_fd_sc_hd__decap_3
XFILLER_60_297 VGND VGND VPWR VPWR sky130_fd_sc_hd__decap_3
X_4770_ _4770_/A1 _3692_/X _5663_/A _4791_/C1 VGND VGND VPWR VPWR _4770_/X sky130_fd_sc_hd__a211o_2
XTAP_TAPCELL_ROW_99_1501 VGND VPWR sky130_fd_sc_hd__tapvpwrvgnd_1
XFILLER_119_528 VGND VGND VPWR VPWR sky130_fd_sc_hd__decap_3
X_3721_ _6863_/Q _3910_/B1 _5660_/B _6855_/Q _3720_/X VGND VGND VPWR VPWR _3721_/X
+ sky130_fd_sc_hd__a221o_2
XTAP_TAPCELL_ROW_31_646 VGND VPWR sky130_fd_sc_hd__tapvpwrvgnd_1
X_6440_ _6624_/A VGND VGND VPWR VPWR _6440_/Y sky130_fd_sc_hd__inv_2
X_6371_ _6563_/A VGND VGND VPWR VPWR _6371_/Y sky130_fd_sc_hd__inv_2
X_3583_ _3583_/A _3583_/B _3583_/C VGND VGND VPWR VPWR _3583_/X sky130_fd_sc_hd__or3_4
XTAP_TAPCELL_ROW_11_392 VGND VPWR sky130_fd_sc_hd__tapvpwrvgnd_1
XFILLER_115_712 VGND VGND VPWR VPWR sky130_fd_sc_hd__fill_2
XFILLER_87_106 VGND VGND VPWR VPWR sky130_fd_sc_hd__decap_3
XFILLER_88_618 VGND VGND VPWR VPWR sky130_fd_sc_hd__decap_3
X_5253_ _5253_/A0 _4913_/X _5274_/S VGND VGND VPWR VPWR _7203_/D sky130_fd_sc_hd__mux2_2
XFILLER_68_331 VGND VGND VPWR VPWR sky130_fd_sc_hd__decap_3
XFILLER_87_128 VGND VGND VPWR VPWR sky130_fd_sc_hd__fill_2
XFILLER_96_640 VGND VGND VPWR VPWR sky130_fd_sc_hd__decap_3
X_5184_ _5184_/A _5198_/B VGND VGND VPWR VPWR _7236_/D sky130_fd_sc_hd__and2_2
X_4204_ _4936_/A _4201_/X _4203_/X VGND VGND VPWR VPWR _4204_/Y sky130_fd_sc_hd__o21bai_2
XFILLER_68_353 VGND VGND VPWR VPWR sky130_fd_sc_hd__decap_3
XFILLER_96_651 VGND VGND VPWR VPWR sky130_fd_sc_hd__decap_3
X_4135_ _7107_/Q _4417_/B1 _4351_/B1 _7139_/Q VGND VGND VPWR VPWR _4135_/X sky130_fd_sc_hd__a22o_2
XFILLER_28_206 VGND VGND VPWR VPWR sky130_fd_sc_hd__fill_2
XFILLER_56_515 VGND VGND VPWR VPWR sky130_fd_sc_hd__fill_2
XFILLER_56_526 VGND VGND VPWR VPWR sky130_fd_sc_hd__decap_3
XFILLER_95_172 VGND VGND VPWR VPWR sky130_fd_sc_hd__decap_3
XFILLER_96_684 VGND VGND VPWR VPWR sky130_fd_sc_hd__decap_3
XFILLER_113_38 VGND VGND VPWR VPWR sky130_fd_sc_hd__decap_3
XFILLER_83_334 VGND VGND VPWR VPWR sky130_fd_sc_hd__fill_2
XFILLER_83_356 VGND VGND VPWR VPWR sky130_fd_sc_hd__decap_3
X_4066_ _4062_/X _4065_/X _4425_/A VGND VGND VPWR VPWR _4082_/A sky130_fd_sc_hd__o21a_2
XTAP_TAPCELL_ROW_39_746 VGND VPWR sky130_fd_sc_hd__tapvpwrvgnd_1
XFILLER_24_401 VGND VGND VPWR VPWR sky130_fd_sc_hd__decap_3
XFILLER_52_710 VGND VGND VPWR VPWR sky130_fd_sc_hd__decap_3
XFILLER_71_529 VGND VGND VPWR VPWR sky130_fd_sc_hd__fill_1
XFILLER_36_294 VGND VGND VPWR VPWR sky130_fd_sc_hd__decap_3
XTAP_TAPCELL_ROW_19_492 VGND VPWR sky130_fd_sc_hd__tapvpwrvgnd_1
XFILLER_12_607 VGND VGND VPWR VPWR sky130_fd_sc_hd__decap_3
XFILLER_24_467 VGND VGND VPWR VPWR sky130_fd_sc_hd__decap_3
XFILLER_51_264 VGND VGND VPWR VPWR sky130_fd_sc_hd__decap_3
XFILLER_24_489 VGND VGND VPWR VPWR sky130_fd_sc_hd__decap_3
X_4968_ _4968_/A _4967_/B VGND VGND VPWR VPWR _4968_/Y sky130_fd_sc_hd__nor2b_2
XFILLER_20_640 VGND VGND VPWR VPWR sky130_fd_sc_hd__decap_3
XFILLER_20_651 VGND VGND VPWR VPWR sky130_fd_sc_hd__decap_3
X_6707_ _6941_/CLK _6707_/D VGND VGND VPWR VPWR _6707_/Q sky130_fd_sc_hd__dfxtp_2
X_4899_ _4836_/S _6998_/D _5656_/B _4898_/X VGND VGND VPWR VPWR _4899_/X sky130_fd_sc_hd__o22a_2
X_3919_ _3682_/A _3918_/X _4791_/A1 VGND VGND VPWR VPWR _3919_/X sky130_fd_sc_hd__a21o_2
XFILLER_20_684 VGND VGND VPWR VPWR sky130_fd_sc_hd__decap_3
XFILLER_22_46 VGND VGND VPWR VPWR sky130_fd_sc_hd__fill_2
X_6638_ _6638_/A VGND VGND VPWR VPWR _6638_/Y sky130_fd_sc_hd__inv_2
XFILLER_106_701 VGND VGND VPWR VPWR sky130_fd_sc_hd__decap_3
XFILLER_22_68 VGND VGND VPWR VPWR sky130_fd_sc_hd__decap_3
X_6569_ _6570_/A VGND VGND VPWR VPWR _6569_/Y sky130_fd_sc_hd__inv_2
XFILLER_3_349 VGND VGND VPWR VPWR sky130_fd_sc_hd__decap_3
XFILLER_105_277 VGND VGND VPWR VPWR sky130_fd_sc_hd__decap_3
XFILLER_78_106 VGND VGND VPWR VPWR sky130_fd_sc_hd__decap_3
XFILLER_79_629 VGND VGND VPWR VPWR sky130_fd_sc_hd__decap_3
XFILLER_78_139 VGND VGND VPWR VPWR sky130_fd_sc_hd__fill_1
XFILLER_87_640 VGND VGND VPWR VPWR sky130_fd_sc_hd__decap_3
XFILLER_86_150 VGND VGND VPWR VPWR sky130_fd_sc_hd__decap_3
XFILLER_87_673 VGND VGND VPWR VPWR sky130_fd_sc_hd__decap_3
XFILLER_19_217 VGND VGND VPWR VPWR sky130_fd_sc_hd__decap_3
XFILLER_19_228 VGND VGND VPWR VPWR sky130_fd_sc_hd__decap_3
XFILLER_47_537 VGND VGND VPWR VPWR sky130_fd_sc_hd__fill_2
XFILLER_59_386 VGND VGND VPWR VPWR sky130_fd_sc_hd__decap_3
XFILLER_74_312 VGND VGND VPWR VPWR sky130_fd_sc_hd__decap_3
XFILLER_86_183 VGND VGND VPWR VPWR sky130_fd_sc_hd__decap_3
XFILLER_101_494 VGND VGND VPWR VPWR sky130_fd_sc_hd__decap_3
XFILLER_47_65 VGND VGND VPWR VPWR sky130_fd_sc_hd__fill_1
XFILLER_103_60 VGND VGND VPWR VPWR sky130_fd_sc_hd__decap_3
XFILLER_55_570 VGND VGND VPWR VPWR sky130_fd_sc_hd__fill_2
XFILLER_15_434 VGND VGND VPWR VPWR sky130_fd_sc_hd__decap_3
XFILLER_42_253 VGND VGND VPWR VPWR sky130_fd_sc_hd__decap_3
XPHY_EDGE_ROW_69_Right_69 VGND VGND VPWR VPWR sky130_fd_sc_hd__decap_3
XFILLER_70_595 VGND VGND VPWR VPWR sky130_fd_sc_hd__decap_3
XFILLER_7_600 VGND VGND VPWR VPWR sky130_fd_sc_hd__decap_3
XPHY_EDGE_ROW_7_Left_127 VGND VGND VPWR VPWR sky130_fd_sc_hd__decap_3
XFILLER_11_662 VGND VGND VPWR VPWR sky130_fd_sc_hd__decap_3
XFILLER_11_673 VGND VGND VPWR VPWR sky130_fd_sc_hd__decap_3
XFILLER_7_644 VGND VGND VPWR VPWR sky130_fd_sc_hd__decap_3
XFILLER_109_561 VGND VGND VPWR VPWR sky130_fd_sc_hd__decap_3
XFILLER_7_688 VGND VGND VPWR VPWR sky130_fd_sc_hd__decap_3
XTAP_TAPCELL_ROW_94_1431 VGND VPWR sky130_fd_sc_hd__tapvpwrvgnd_1
XPHY_EDGE_ROW_78_Right_78 VGND VGND VPWR VPWR sky130_fd_sc_hd__decap_3
XFILLER_112_704 VGND VGND VPWR VPWR sky130_fd_sc_hd__decap_3
XFILLER_88_61 VGND VGND VPWR VPWR sky130_fd_sc_hd__decap_3
XFILLER_97_415 VGND VGND VPWR VPWR sky130_fd_sc_hd__fill_1
XFILLER_88_94 VGND VGND VPWR VPWR sky130_fd_sc_hd__decap_3
XFILLER_97_437 VGND VGND VPWR VPWR sky130_fd_sc_hd__decap_3
XFILLER_97_459 VGND VGND VPWR VPWR sky130_fd_sc_hd__decap_3
XFILLER_111_247 VGND VGND VPWR VPWR sky130_fd_sc_hd__decap_3
XFILLER_78_651 VGND VGND VPWR VPWR sky130_fd_sc_hd__decap_3
XFILLER_84_109 VGND VGND VPWR VPWR sky130_fd_sc_hd__decap_3
XFILLER_77_150 VGND VGND VPWR VPWR sky130_fd_sc_hd__fill_1
XFILLER_78_684 VGND VGND VPWR VPWR sky130_fd_sc_hd__decap_3
XFILLER_93_610 VGND VGND VPWR VPWR sky130_fd_sc_hd__decap_3
XFILLER_93_632 VGND VGND VPWR VPWR sky130_fd_sc_hd__decap_3
XFILLER_93_665 VGND VGND VPWR VPWR sky130_fd_sc_hd__decap_3
XFILLER_18_261 VGND VGND VPWR VPWR sky130_fd_sc_hd__decap_3
XFILLER_34_710 VGND VGND VPWR VPWR sky130_fd_sc_hd__decap_3
XFILLER_80_315 VGND VGND VPWR VPWR sky130_fd_sc_hd__decap_3
XFILLER_92_153 VGND VGND VPWR VPWR sky130_fd_sc_hd__decap_3
XFILLER_93_676 VGND VGND VPWR VPWR sky130_fd_sc_hd__decap_3
XTAP_TAPCELL_ROW_36_705 VGND VPWR sky130_fd_sc_hd__tapvpwrvgnd_1
XFILLER_46_592 VGND VGND VPWR VPWR sky130_fd_sc_hd__decap_3
XFILLER_92_197 VGND VGND VPWR VPWR sky130_fd_sc_hd__decap_3
XPHY_EDGE_ROW_87_Right_87 VGND VGND VPWR VPWR sky130_fd_sc_hd__decap_3
XFILLER_33_231 VGND VGND VPWR VPWR sky130_fd_sc_hd__decap_3
XFILLER_33_242 VGND VGND VPWR VPWR sky130_fd_sc_hd__decap_3
XFILLER_61_551 VGND VGND VPWR VPWR sky130_fd_sc_hd__decap_3
XFILLER_21_415 VGND VGND VPWR VPWR sky130_fd_sc_hd__decap_3
XFILLER_21_437 VGND VGND VPWR VPWR sky130_fd_sc_hd__decap_3
XFILLER_61_573 VGND VGND VPWR VPWR sky130_fd_sc_hd__decap_3
X_4822_ _4836_/S _7002_/D _5663_/B _4821_/X VGND VGND VPWR VPWR _4822_/X sky130_fd_sc_hd__o22a_2
XTAP_TAPCELL_ROW_16_462 VGND VPWR sky130_fd_sc_hd__tapvpwrvgnd_1
X_4753_ _4753_/A0 _4752_/X _4865_/S VGND VGND VPWR VPWR _7276_/D sky130_fd_sc_hd__mux2_2
X_3704_ _6712_/Q _3760_/B1 _3767_/B1 _6890_/Q _3703_/X VGND VGND VPWR VPWR _3704_/X
+ sky130_fd_sc_hd__a221o_2
XFILLER_119_358 VGND VGND VPWR VPWR sky130_fd_sc_hd__decap_3
X_6423_ _6651_/A VGND VGND VPWR VPWR _6423_/Y sky130_fd_sc_hd__inv_2
X_4684_ _6996_/Q _4668_/X _4943_/A _4683_/X VGND VGND VPWR VPWR _4684_/X sky130_fd_sc_hd__a31o_2
X_3635_ _3635_/A _3635_/B _3547_/A VGND VGND VPWR VPWR _3635_/X sky130_fd_sc_hd__or3b_2
XPHY_EDGE_ROW_96_Right_96 VGND VGND VPWR VPWR sky130_fd_sc_hd__decap_3
XFILLER_108_27 VGND VGND VPWR VPWR sky130_fd_sc_hd__fill_1
XFILLER_108_38 VGND VGND VPWR VPWR sky130_fd_sc_hd__decap_3
XFILLER_115_520 VGND VGND VPWR VPWR sky130_fd_sc_hd__fill_1
X_6354_ _6677_/A VGND VGND VPWR VPWR _6354_/Y sky130_fd_sc_hd__inv_2
X_3566_ _7189_/Q _3566_/A2 _4285_/B1 _7381_/Q VGND VGND VPWR VPWR _3566_/X sky130_fd_sc_hd__a22o_2
XFILLER_115_575 VGND VGND VPWR VPWR sky130_fd_sc_hd__decap_3
XFILLER_88_404 VGND VGND VPWR VPWR sky130_fd_sc_hd__decap_3
X_6285_ _6288_/A VGND VGND VPWR VPWR _6285_/Y sky130_fd_sc_hd__inv_2
X_3497_ _7151_/Q _3409_/X _3493_/X _3496_/X VGND VGND VPWR VPWR _3497_/X sky130_fd_sc_hd__a211o_2
XFILLER_102_225 VGND VGND VPWR VPWR sky130_fd_sc_hd__decap_3
XFILLER_102_236 VGND VGND VPWR VPWR sky130_fd_sc_hd__decap_3
X_5236_ _5236_/A0 _4752_/X _5272_/S VGND VGND VPWR VPWR _7212_/D sky130_fd_sc_hd__mux2_2
XFILLER_69_662 VGND VGND VPWR VPWR sky130_fd_sc_hd__decap_3
XFILLER_75_109 VGND VGND VPWR VPWR sky130_fd_sc_hd__decap_3
XFILLER_56_312 VGND VGND VPWR VPWR sky130_fd_sc_hd__decap_3
XFILLER_68_150 VGND VGND VPWR VPWR sky130_fd_sc_hd__decap_3
XFILLER_69_673 VGND VGND VPWR VPWR sky130_fd_sc_hd__decap_3
X_5167_ _5167_/A _5198_/B VGND VGND VPWR VPWR _7244_/D sky130_fd_sc_hd__and2_2
XFILLER_56_356 VGND VGND VPWR VPWR sky130_fd_sc_hd__decap_3
XFILLER_68_183 VGND VGND VPWR VPWR sky130_fd_sc_hd__decap_3
XFILLER_68_194 VGND VGND VPWR VPWR sky130_fd_sc_hd__fill_2
XFILLER_84_643 VGND VGND VPWR VPWR sky130_fd_sc_hd__fill_1
XFILLER_84_654 VGND VGND VPWR VPWR sky130_fd_sc_hd__decap_3
X_5098_ _5098_/A _5098_/B VGND VGND VPWR VPWR _6985_/D sky130_fd_sc_hd__nor2_2
X_4118_ _7021_/Q _4131_/A2 _4272_/B _7364_/Q VGND VGND VPWR VPWR _4118_/X sky130_fd_sc_hd__a22o_2
XFILLER_83_153 VGND VGND VPWR VPWR sky130_fd_sc_hd__decap_3
XFILLER_83_175 VGND VGND VPWR VPWR sky130_fd_sc_hd__decap_3
XFILLER_84_687 VGND VGND VPWR VPWR sky130_fd_sc_hd__decap_3
X_4049_ _7213_/Q _3954_/S _4865_/S _7309_/Q _4048_/X VGND VGND VPWR VPWR _4049_/X
+ sky130_fd_sc_hd__a221o_2
XFILLER_17_57 VGND VGND VPWR VPWR sky130_fd_sc_hd__decap_3
XFILLER_71_337 VGND VGND VPWR VPWR sky130_fd_sc_hd__decap_3
XTAP_TAPCELL_ROW_65_1065 VGND VPWR sky130_fd_sc_hd__tapvpwrvgnd_1
XFILLER_33_23 VGND VGND VPWR VPWR sky130_fd_sc_hd__decap_3
XFILLER_40_713 VGND VGND VPWR VPWR sky130_fd_sc_hd__fill_1
XTAP_TAPCELL_ROW_65_1076 VGND VPWR sky130_fd_sc_hd__tapvpwrvgnd_1
XFILLER_8_419 VGND VGND VPWR VPWR sky130_fd_sc_hd__fill_1
XFILLER_20_470 VGND VGND VPWR VPWR sky130_fd_sc_hd__decap_3
XTAP_TAPCELL_ROW_117_1718 VGND VPWR sky130_fd_sc_hd__tapvpwrvgnd_1
XFILLER_116_3 VGND VGND VPWR VPWR sky130_fd_sc_hd__decap_3
XFILLER_3_102 VGND VGND VPWR VPWR sky130_fd_sc_hd__fill_2
XFILLER_4_614 VGND VGND VPWR VPWR sky130_fd_sc_hd__decap_3
XFILLER_106_542 VGND VGND VPWR VPWR sky130_fd_sc_hd__fill_2
XFILLER_3_113 VGND VGND VPWR VPWR sky130_fd_sc_hd__decap_3
XFILLER_4_669 VGND VGND VPWR VPWR sky130_fd_sc_hd__decap_3
XFILLER_94_407 VGND VGND VPWR VPWR sky130_fd_sc_hd__decap_3
XFILLER_47_301 VGND VGND VPWR VPWR sky130_fd_sc_hd__decap_3
XFILLER_59_161 VGND VGND VPWR VPWR sky130_fd_sc_hd__decap_3
XFILLER_75_610 VGND VGND VPWR VPWR sky130_fd_sc_hd__decap_3
XFILLER_87_470 VGND VGND VPWR VPWR sky130_fd_sc_hd__decap_3
XFILLER_75_632 VGND VGND VPWR VPWR sky130_fd_sc_hd__decap_3
XFILLER_75_665 VGND VGND VPWR VPWR sky130_fd_sc_hd__decap_3
XFILLER_16_710 VGND VGND VPWR VPWR sky130_fd_sc_hd__decap_3
XFILLER_47_367 VGND VGND VPWR VPWR sky130_fd_sc_hd__decap_3
XFILLER_74_153 VGND VGND VPWR VPWR sky130_fd_sc_hd__decap_3
XFILLER_75_676 VGND VGND VPWR VPWR sky130_fd_sc_hd__decap_3
XFILLER_28_592 VGND VGND VPWR VPWR sky130_fd_sc_hd__decap_3
XFILLER_74_186 VGND VGND VPWR VPWR sky130_fd_sc_hd__decap_3
XFILLER_74_197 VGND VGND VPWR VPWR sky130_fd_sc_hd__decap_3
XFILLER_74_74 VGND VGND VPWR VPWR sky130_fd_sc_hd__decap_3
XFILLER_74_85 VGND VGND VPWR VPWR sky130_fd_sc_hd__decap_3
XFILLER_90_657 VGND VGND VPWR VPWR sky130_fd_sc_hd__decap_3
XFILLER_15_231 VGND VGND VPWR VPWR sky130_fd_sc_hd__decap_3
XFILLER_62_359 VGND VGND VPWR VPWR sky130_fd_sc_hd__decap_3
XFILLER_30_223 VGND VGND VPWR VPWR sky130_fd_sc_hd__decap_3
XFILLER_90_73 VGND VGND VPWR VPWR sky130_fd_sc_hd__decap_3
XTAP_TAPCELL_ROW_13_421 VGND VPWR sky130_fd_sc_hd__tapvpwrvgnd_1
XFILLER_30_278 VGND VGND VPWR VPWR sky130_fd_sc_hd__decap_3
XTAP_TAPCELL_ROW_41_774 VGND VPWR sky130_fd_sc_hd__tapvpwrvgnd_1
XFILLER_11_470 VGND VGND VPWR VPWR sky130_fd_sc_hd__decap_3
XFILLER_7_463 VGND VGND VPWR VPWR sky130_fd_sc_hd__decap_3
X_3420_ _3420_/A _5642_/B VGND VGND VPWR VPWR _3442_/B sky130_fd_sc_hd__or2_2
XFILLER_99_71 VGND VGND VPWR VPWR sky130_fd_sc_hd__decap_3
XFILLER_99_60 VGND VGND VPWR VPWR sky130_fd_sc_hd__decap_3
XFILLER_97_201 VGND VGND VPWR VPWR sky130_fd_sc_hd__decap_3
X_3351_ _5130_/A _3350_/Y _3340_/B VGND VGND VPWR VPWR _5642_/B sky130_fd_sc_hd__o21a_2
XFILLER_98_713 VGND VGND VPWR VPWR sky130_fd_sc_hd__fill_1
XFILLER_112_523 VGND VGND VPWR VPWR sky130_fd_sc_hd__fill_2
XFILLER_3_691 VGND VGND VPWR VPWR sky130_fd_sc_hd__decap_3
XFILLER_100_707 VGND VGND VPWR VPWR sky130_fd_sc_hd__decap_3
XFILLER_97_256 VGND VGND VPWR VPWR sky130_fd_sc_hd__decap_3
XFILLER_112_589 VGND VGND VPWR VPWR sky130_fd_sc_hd__decap_3
XFILLER_38_312 VGND VGND VPWR VPWR sky130_fd_sc_hd__fill_2
XFILLER_78_470 VGND VGND VPWR VPWR sky130_fd_sc_hd__decap_3
XFILLER_85_429 VGND VGND VPWR VPWR sky130_fd_sc_hd__decap_3
Xhold1108 _7263_/Q VGND VGND VPWR VPWR _4979_/A0 sky130_fd_sc_hd__dlygate4sd3_1
Xhold1119 _7262_/Q VGND VGND VPWR VPWR _4998_/A0 sky130_fd_sc_hd__dlygate4sd3_1
X_5021_ _5114_/A _4372_/A _5018_/A _5101_/A VGND VGND VPWR VPWR _5021_/X sky130_fd_sc_hd__o2bb2a_2
XFILLER_38_345 VGND VGND VPWR VPWR sky130_fd_sc_hd__decap_3
XFILLER_65_131 VGND VGND VPWR VPWR sky130_fd_sc_hd__decap_3
XFILLER_66_632 VGND VGND VPWR VPWR sky130_fd_sc_hd__decap_3
XFILLER_66_654 VGND VGND VPWR VPWR sky130_fd_sc_hd__decap_3
XFILLER_93_440 VGND VGND VPWR VPWR sky130_fd_sc_hd__decap_3
XFILLER_26_507 VGND VGND VPWR VPWR sky130_fd_sc_hd__decap_3
XFILLER_65_164 VGND VGND VPWR VPWR sky130_fd_sc_hd__decap_3
XFILLER_66_687 VGND VGND VPWR VPWR sky130_fd_sc_hd__decap_3
XFILLER_81_602 VGND VGND VPWR VPWR sky130_fd_sc_hd__decap_3
XFILLER_93_473 VGND VGND VPWR VPWR sky130_fd_sc_hd__decap_3
XTAP_TAPCELL_ROW_49_874 VGND VPWR sky130_fd_sc_hd__tapvpwrvgnd_1
XFILLER_19_592 VGND VGND VPWR VPWR sky130_fd_sc_hd__decap_3
XFILLER_80_112 VGND VGND VPWR VPWR sky130_fd_sc_hd__decap_3
XFILLER_81_635 VGND VGND VPWR VPWR sky130_fd_sc_hd__decap_3
X_6972_ clkload4/A _6972_/D VGND VGND VPWR VPWR _6972_/Q sky130_fd_sc_hd__dfxtp_2
XFILLER_110_17 VGND VGND VPWR VPWR sky130_fd_sc_hd__decap_3
XFILLER_80_167 VGND VGND VPWR VPWR sky130_fd_sc_hd__decap_3
XFILLER_81_668 VGND VGND VPWR VPWR sky130_fd_sc_hd__decap_3
XFILLER_81_679 VGND VGND VPWR VPWR sky130_fd_sc_hd__decap_3
XFILLER_22_713 VGND VGND VPWR VPWR sky130_fd_sc_hd__fill_1
XFILLER_34_584 VGND VGND VPWR VPWR sky130_fd_sc_hd__decap_3
XFILLER_34_595 VGND VGND VPWR VPWR sky130_fd_sc_hd__decap_3
XFILLER_80_189 VGND VGND VPWR VPWR sky130_fd_sc_hd__decap_3
XTAP_TAPCELL_ROW_101_1519 VGND VPWR sky130_fd_sc_hd__tapvpwrvgnd_1
XFILLER_21_234 VGND VGND VPWR VPWR sky130_fd_sc_hd__decap_3
XFILLER_21_245 VGND VGND VPWR VPWR sky130_fd_sc_hd__decap_3
X_4805_ _5666_/A _7003_/D _4804_/X VGND VGND VPWR VPWR _4805_/X sky130_fd_sc_hd__a21bo_2
XFILLER_119_144 VGND VGND VPWR VPWR sky130_fd_sc_hd__decap_3
XFILLER_119_48 VGND VGND VPWR VPWR sky130_fd_sc_hd__decap_3
X_4667_ _6998_/Q _5602_/B VGND VGND VPWR VPWR _4896_/A sky130_fd_sc_hd__xnor2_2
X_7386_ _7390_/CLK _7386_/D _6666_/Y VGND VGND VPWR VPWR _7386_/Q sky130_fd_sc_hd__dfrtp_2
Xhold920 _6902_/Q VGND VGND VPWR VPWR _6902_/D sky130_fd_sc_hd__dlygate4sd3_1
Xhold931 _6766_/Q VGND VGND VPWR VPWR _6766_/D sky130_fd_sc_hd__dlygate4sd3_1
X_6406_ _6563_/A VGND VGND VPWR VPWR _6406_/Y sky130_fd_sc_hd__inv_2
X_3618_ _5118_/C _4938_/A _3618_/C VGND VGND VPWR VPWR _3618_/X sky130_fd_sc_hd__and3_2
XFILLER_1_606 VGND VGND VPWR VPWR sky130_fd_sc_hd__decap_3
XFILLER_1_617 VGND VGND VPWR VPWR sky130_fd_sc_hd__decap_3
Xhold942 _7087_/Q VGND VGND VPWR VPWR _7087_/D sky130_fd_sc_hd__dlygate4sd3_1
Xhold953 _7061_/Q VGND VGND VPWR VPWR _7061_/D sky130_fd_sc_hd__dlygate4sd3_1
Xhold964 _7108_/Q VGND VGND VPWR VPWR _7108_/D sky130_fd_sc_hd__dlygate4sd3_1
X_6337_ _6533_/A VGND VGND VPWR VPWR _6337_/Y sky130_fd_sc_hd__inv_2
XFILLER_103_523 VGND VGND VPWR VPWR sky130_fd_sc_hd__decap_3
XFILLER_88_212 VGND VGND VPWR VPWR sky130_fd_sc_hd__decap_3
Xhold975 _7111_/Q VGND VGND VPWR VPWR _7111_/D sky130_fd_sc_hd__dlygate4sd3_1
Xhold997 _7090_/Q VGND VGND VPWR VPWR _7090_/D sky130_fd_sc_hd__dlygate4sd3_1
Xhold986 _7081_/Q VGND VGND VPWR VPWR _7081_/D sky130_fd_sc_hd__dlygate4sd3_1
XTAP_TAPCELL_ROW_112_1659 VGND VPWR sky130_fd_sc_hd__tapvpwrvgnd_1
XFILLER_88_245 VGND VGND VPWR VPWR sky130_fd_sc_hd__decap_3
XFILLER_88_256 VGND VGND VPWR VPWR sky130_fd_sc_hd__decap_3
X_6268_ _6678_/A VGND VGND VPWR VPWR _6268_/Y sky130_fd_sc_hd__inv_2
XFILLER_29_301 VGND VGND VPWR VPWR sky130_fd_sc_hd__decap_3
XFILLER_69_481 VGND VGND VPWR VPWR sky130_fd_sc_hd__decap_3
XFILLER_88_289 VGND VGND VPWR VPWR sky130_fd_sc_hd__decap_3
X_5219_ _5219_/A _5225_/B VGND VGND VPWR VPWR _7219_/D sky130_fd_sc_hd__and2_2
XFILLER_29_334 VGND VGND VPWR VPWR sky130_fd_sc_hd__fill_2
XFILLER_57_632 VGND VGND VPWR VPWR sky130_fd_sc_hd__decap_3
XFILLER_28_78 VGND VGND VPWR VPWR sky130_fd_sc_hd__decap_3
XFILLER_29_367 VGND VGND VPWR VPWR sky130_fd_sc_hd__decap_3
XFILLER_56_153 VGND VGND VPWR VPWR sky130_fd_sc_hd__decap_3
XFILLER_57_665 VGND VGND VPWR VPWR sky130_fd_sc_hd__decap_3
XFILLER_57_676 VGND VGND VPWR VPWR sky130_fd_sc_hd__decap_3
XFILLER_72_613 VGND VGND VPWR VPWR sky130_fd_sc_hd__decap_3
XFILLER_84_462 VGND VGND VPWR VPWR sky130_fd_sc_hd__decap_3
XFILLER_44_315 VGND VGND VPWR VPWR sky130_fd_sc_hd__fill_1
XFILLER_44_337 VGND VGND VPWR VPWR sky130_fd_sc_hd__decap_3
XFILLER_56_197 VGND VGND VPWR VPWR sky130_fd_sc_hd__fill_2
XFILLER_72_657 VGND VGND VPWR VPWR sky130_fd_sc_hd__decap_3
XPHY_EDGE_ROW_88_Left_208 VGND VGND VPWR VPWR sky130_fd_sc_hd__decap_3
XFILLER_71_156 VGND VGND VPWR VPWR sky130_fd_sc_hd__decap_3
XFILLER_25_595 VGND VGND VPWR VPWR sky130_fd_sc_hd__decap_3
XFILLER_40_510 VGND VGND VPWR VPWR sky130_fd_sc_hd__decap_3
XFILLER_71_178 VGND VGND VPWR VPWR sky130_fd_sc_hd__decap_3
XFILLER_40_554 VGND VGND VPWR VPWR sky130_fd_sc_hd__decap_3
XFILLER_44_88 VGND VGND VPWR VPWR sky130_fd_sc_hd__decap_3
XFILLER_52_392 VGND VGND VPWR VPWR sky130_fd_sc_hd__fill_1
XFILLER_80_690 VGND VGND VPWR VPWR sky130_fd_sc_hd__decap_3
XFILLER_9_706 VGND VGND VPWR VPWR sky130_fd_sc_hd__decap_3
XFILLER_12_278 VGND VGND VPWR VPWR sky130_fd_sc_hd__fill_2
XFILLER_100_83 VGND VGND VPWR VPWR sky130_fd_sc_hd__fill_1
XFILLER_100_94 VGND VGND VPWR VPWR sky130_fd_sc_hd__fill_2
XFILLER_40_598 VGND VGND VPWR VPWR sky130_fd_sc_hd__decap_3
XFILLER_60_32 VGND VGND VPWR VPWR sky130_fd_sc_hd__fill_1
XFILLER_8_249 VGND VGND VPWR VPWR sky130_fd_sc_hd__decap_3
XTAP_TAPCELL_ROW_78_1234 VGND VPWR sky130_fd_sc_hd__tapvpwrvgnd_1
XPHY_EDGE_ROW_97_Left_217 VGND VGND VPWR VPWR sky130_fd_sc_hd__decap_3
XFILLER_109_81 VGND VGND VPWR VPWR sky130_fd_sc_hd__fill_1
XFILLER_4_477 VGND VGND VPWR VPWR sky130_fd_sc_hd__decap_3
XTAP_TAPCELL_ROW_91_1401 VGND VPWR sky130_fd_sc_hd__tapvpwrvgnd_1
XFILLER_106_361 VGND VGND VPWR VPWR sky130_fd_sc_hd__decap_3
XFILLER_106_383 VGND VGND VPWR VPWR sky130_fd_sc_hd__decap_3
XFILLER_69_63 VGND VGND VPWR VPWR sky130_fd_sc_hd__decap_3
XFILLER_79_234 VGND VGND VPWR VPWR sky130_fd_sc_hd__decap_3
XFILLER_67_429 VGND VGND VPWR VPWR sky130_fd_sc_hd__decap_3
XFILLER_0_694 VGND VGND VPWR VPWR sky130_fd_sc_hd__decap_3
XFILLER_48_632 VGND VGND VPWR VPWR sky130_fd_sc_hd__decap_3
XFILLER_48_654 VGND VGND VPWR VPWR sky130_fd_sc_hd__decap_3
XFILLER_94_259 VGND VGND VPWR VPWR sky130_fd_sc_hd__fill_1
XFILLER_48_687 VGND VGND VPWR VPWR sky130_fd_sc_hd__decap_3
XFILLER_85_84 VGND VGND VPWR VPWR sky130_fd_sc_hd__decap_3
XTAP_TAPCELL_ROW_89_1374 VGND VPWR sky130_fd_sc_hd__tapvpwrvgnd_1
XFILLER_35_315 VGND VGND VPWR VPWR sky130_fd_sc_hd__fill_1
XFILLER_35_337 VGND VGND VPWR VPWR sky130_fd_sc_hd__decap_3
XFILLER_47_175 VGND VGND VPWR VPWR sky130_fd_sc_hd__fill_2
XFILLER_62_123 VGND VGND VPWR VPWR sky130_fd_sc_hd__decap_3
XFILLER_63_635 VGND VGND VPWR VPWR sky130_fd_sc_hd__decap_3
XFILLER_90_421 VGND VGND VPWR VPWR sky130_fd_sc_hd__decap_3
XTAP_TAPCELL_ROW_46_833 VGND VPWR sky130_fd_sc_hd__tapvpwrvgnd_1
XFILLER_63_668 VGND VGND VPWR VPWR sky130_fd_sc_hd__decap_3
XFILLER_63_679 VGND VGND VPWR VPWR sky130_fd_sc_hd__decap_3
XFILLER_16_584 VGND VGND VPWR VPWR sky130_fd_sc_hd__decap_3
XFILLER_50_307 VGND VGND VPWR VPWR sky130_fd_sc_hd__fill_1
XFILLER_62_167 VGND VGND VPWR VPWR sky130_fd_sc_hd__decap_3
XFILLER_16_595 VGND VGND VPWR VPWR sky130_fd_sc_hd__decap_3
XFILLER_31_565 VGND VGND VPWR VPWR sky130_fd_sc_hd__decap_3
XFILLER_31_598 VGND VGND VPWR VPWR sky130_fd_sc_hd__decap_3
XFILLER_79_3 VGND VGND VPWR VPWR sky130_fd_sc_hd__decap_3
X_5570_ _5570_/A1 _4857_/A _4929_/Y VGND VGND VPWR VPWR _7047_/D sky130_fd_sc_hd__o21a_2
XFILLER_116_103 VGND VGND VPWR VPWR sky130_fd_sc_hd__decap_3
XFILLER_117_615 VGND VGND VPWR VPWR sky130_fd_sc_hd__fill_1
XFILLER_117_626 VGND VGND VPWR VPWR sky130_fd_sc_hd__decap_3
XFILLER_116_136 VGND VGND VPWR VPWR sky130_fd_sc_hd__decap_3
XFILLER_117_659 VGND VGND VPWR VPWR sky130_fd_sc_hd__decap_3
XFILLER_7_293 VGND VGND VPWR VPWR sky130_fd_sc_hd__decap_3
X_7240_ _7342_/CLK _7240_/D _6520_/Y VGND VGND VPWR VPWR _7240_/Q sky130_fd_sc_hd__dfrtp_2
X_4452_ _4452_/A _4765_/B VGND VGND VPWR VPWR _4453_/A sky130_fd_sc_hd__or2_2
XFILLER_116_147 VGND VGND VPWR VPWR sky130_fd_sc_hd__decap_3
X_3403_ _5667_/A _4467_/B VGND VGND VPWR VPWR _5602_/B sky130_fd_sc_hd__or2_4
X_7171_ _7400_/CLK _7171_/D _6451_/Y VGND VGND VPWR VPWR _7171_/Q sky130_fd_sc_hd__dfrtp_2
X_4383_ _4920_/A _4937_/A _4383_/C VGND VGND VPWR VPWR _4384_/C sky130_fd_sc_hd__and3_2
XFILLER_98_554 VGND VGND VPWR VPWR sky130_fd_sc_hd__decap_3
X_3334_ _3330_/Y _3528_/A _3341_/A VGND VGND VPWR VPWR _3334_/Y sky130_fd_sc_hd__o21ai_2
XFILLER_39_610 VGND VGND VPWR VPWR sky130_fd_sc_hd__decap_3
XFILLER_85_204 VGND VGND VPWR VPWR sky130_fd_sc_hd__decap_3
XFILLER_112_397 VGND VGND VPWR VPWR sky130_fd_sc_hd__fill_2
XFILLER_39_632 VGND VGND VPWR VPWR sky130_fd_sc_hd__decap_3
XFILLER_85_237 VGND VGND VPWR VPWR sky130_fd_sc_hd__decap_3
X_5004_ _5004_/A _5004_/B VGND VGND VPWR VPWR _5004_/X sky130_fd_sc_hd__or2_2
XFILLER_38_164 VGND VGND VPWR VPWR sky130_fd_sc_hd__decap_3
XFILLER_39_665 VGND VGND VPWR VPWR sky130_fd_sc_hd__decap_3
XFILLER_39_676 VGND VGND VPWR VPWR sky130_fd_sc_hd__decap_3
XFILLER_26_326 VGND VGND VPWR VPWR sky130_fd_sc_hd__decap_3
XFILLER_38_197 VGND VGND VPWR VPWR sky130_fd_sc_hd__decap_3
XFILLER_53_101 VGND VGND VPWR VPWR sky130_fd_sc_hd__decap_3
XFILLER_54_624 VGND VGND VPWR VPWR sky130_fd_sc_hd__decap_3
XFILLER_81_421 VGND VGND VPWR VPWR sky130_fd_sc_hd__decap_3
XFILLER_93_281 VGND VGND VPWR VPWR sky130_fd_sc_hd__decap_3
XFILLER_54_657 VGND VGND VPWR VPWR sky130_fd_sc_hd__decap_3
XFILLER_81_465 VGND VGND VPWR VPWR sky130_fd_sc_hd__fill_1
X_6955_ clkload5/A _6955_/D VGND VGND VPWR VPWR _6955_/Q sky130_fd_sc_hd__dfxtp_2
XFILLER_41_329 VGND VGND VPWR VPWR sky130_fd_sc_hd__fill_2
XFILLER_53_167 VGND VGND VPWR VPWR sky130_fd_sc_hd__fill_1
XFILLER_62_690 VGND VGND VPWR VPWR sky130_fd_sc_hd__decap_3
X_6886_ _6943_/CLK _6886_/D VGND VGND VPWR VPWR _6886_/Q sky130_fd_sc_hd__dfxtp_2
XTAP_TAPCELL_ROW_62_1035 VGND VPWR sky130_fd_sc_hd__tapvpwrvgnd_1
XFILLER_22_598 VGND VGND VPWR VPWR sky130_fd_sc_hd__decap_3
XFILLER_108_604 VGND VGND VPWR VPWR sky130_fd_sc_hd__decap_3
XFILLER_107_125 VGND VGND VPWR VPWR sky130_fd_sc_hd__fill_1
XFILLER_108_637 VGND VGND VPWR VPWR sky130_fd_sc_hd__decap_3
XFILLER_108_648 VGND VGND VPWR VPWR sky130_fd_sc_hd__decap_3
X_5699_ _7355_/Q _5699_/A1 _5708_/S VGND VGND VPWR VPWR _6699_/D sky130_fd_sc_hd__mux2_2
XFILLER_107_158 VGND VGND VPWR VPWR sky130_fd_sc_hd__decap_3
XFILLER_107_169 VGND VGND VPWR VPWR sky130_fd_sc_hd__decap_3
XFILLER_30_57 VGND VGND VPWR VPWR sky130_fd_sc_hd__decap_3
XFILLER_116_681 VGND VGND VPWR VPWR sky130_fd_sc_hd__decap_3
XFILLER_1_403 VGND VGND VPWR VPWR sky130_fd_sc_hd__decap_3
X_7369_ _7402_/CLK _7369_/D _6649_/Y VGND VGND VPWR VPWR _7369_/Q sky130_fd_sc_hd__dfrtp_2
Xhold750 _6833_/Q VGND VGND VPWR VPWR _6833_/D sky130_fd_sc_hd__dlygate4sd3_1
Xhold761 _6768_/Q VGND VGND VPWR VPWR _6768_/D sky130_fd_sc_hd__dlygate4sd3_1
Xhold772 _6872_/Q VGND VGND VPWR VPWR _6872_/D sky130_fd_sc_hd__dlygate4sd3_1
XFILLER_39_11 VGND VGND VPWR VPWR sky130_fd_sc_hd__fill_1
XFILLER_89_543 VGND VGND VPWR VPWR sky130_fd_sc_hd__decap_3
Xhold783 _6961_/Q VGND VGND VPWR VPWR _6961_/D sky130_fd_sc_hd__dlygate4sd3_1
Xhold794 _6901_/Q VGND VGND VPWR VPWR _6901_/D sky130_fd_sc_hd__dlygate4sd3_1
XTAP_TAPCELL_ROW_73_1175 VGND VPWR sky130_fd_sc_hd__tapvpwrvgnd_1
XFILLER_1_469 VGND VGND VPWR VPWR sky130_fd_sc_hd__decap_3
XFILLER_76_204 VGND VGND VPWR VPWR sky130_fd_sc_hd__decap_3
XFILLER_76_237 VGND VGND VPWR VPWR sky130_fd_sc_hd__decap_3
XFILLER_29_142 VGND VGND VPWR VPWR sky130_fd_sc_hd__decap_3
XFILLER_45_602 VGND VGND VPWR VPWR sky130_fd_sc_hd__decap_3
XFILLER_17_326 VGND VGND VPWR VPWR sky130_fd_sc_hd__decap_3
XFILLER_17_337 VGND VGND VPWR VPWR sky130_fd_sc_hd__decap_3
XFILLER_29_175 VGND VGND VPWR VPWR sky130_fd_sc_hd__decap_3
XFILLER_45_635 VGND VGND VPWR VPWR sky130_fd_sc_hd__decap_3
XFILLER_57_495 VGND VGND VPWR VPWR sky130_fd_sc_hd__fill_2
XFILLER_72_421 VGND VGND VPWR VPWR sky130_fd_sc_hd__fill_2
XFILLER_84_281 VGND VGND VPWR VPWR sky130_fd_sc_hd__decap_3
XFILLER_17_359 VGND VGND VPWR VPWR sky130_fd_sc_hd__decap_3
XFILLER_44_134 VGND VGND VPWR VPWR sky130_fd_sc_hd__decap_3
XFILLER_45_668 VGND VGND VPWR VPWR sky130_fd_sc_hd__decap_3
XFILLER_45_679 VGND VGND VPWR VPWR sky130_fd_sc_hd__decap_3
XFILLER_32_318 VGND VGND VPWR VPWR sky130_fd_sc_hd__decap_3
XFILLER_32_329 VGND VGND VPWR VPWR sky130_fd_sc_hd__decap_3
XFILLER_44_178 VGND VGND VPWR VPWR sky130_fd_sc_hd__decap_3
XFILLER_60_616 VGND VGND VPWR VPWR sky130_fd_sc_hd__decap_3
XPHY_EDGE_ROW_105_Right_105 VGND VGND VPWR VPWR sky130_fd_sc_hd__decap_3
XFILLER_111_60 VGND VGND VPWR VPWR sky130_fd_sc_hd__decap_3
XFILLER_13_576 VGND VGND VPWR VPWR sky130_fd_sc_hd__decap_3
XFILLER_9_503 VGND VGND VPWR VPWR sky130_fd_sc_hd__fill_1
XFILLER_40_373 VGND VGND VPWR VPWR sky130_fd_sc_hd__decap_3
XTAP_TAPCELL_ROW_51_891 VGND VPWR sky130_fd_sc_hd__tapvpwrvgnd_1
XFILLER_114_607 VGND VGND VPWR VPWR sky130_fd_sc_hd__decap_3
XFILLER_4_241 VGND VGND VPWR VPWR sky130_fd_sc_hd__decap_3
XFILLER_113_106 VGND VGND VPWR VPWR sky130_fd_sc_hd__decap_3
XFILLER_113_128 VGND VGND VPWR VPWR sky130_fd_sc_hd__decap_3
XFILLER_4_274 VGND VGND VPWR VPWR sky130_fd_sc_hd__decap_3
XFILLER_67_204 VGND VGND VPWR VPWR sky130_fd_sc_hd__decap_3
XFILLER_0_480 VGND VGND VPWR VPWR sky130_fd_sc_hd__decap_3
XFILLER_96_83 VGND VGND VPWR VPWR sky130_fd_sc_hd__fill_1
XFILLER_67_259 VGND VGND VPWR VPWR sky130_fd_sc_hd__decap_3
XFILLER_95_579 VGND VGND VPWR VPWR sky130_fd_sc_hd__decap_3
XFILLER_36_613 VGND VGND VPWR VPWR sky130_fd_sc_hd__decap_3
XFILLER_63_410 VGND VGND VPWR VPWR sky130_fd_sc_hd__decap_3
XFILLER_75_281 VGND VGND VPWR VPWR sky130_fd_sc_hd__fill_2
XTAP_TAPCELL_ROW_59_991 VGND VPWR sky130_fd_sc_hd__tapvpwrvgnd_1
XFILLER_35_145 VGND VGND VPWR VPWR sky130_fd_sc_hd__decap_3
XFILLER_36_657 VGND VGND VPWR VPWR sky130_fd_sc_hd__decap_3
Xplace421 _3558_/B VGND VGND VPWR VPWR _4305_/B sky130_fd_sc_hd__buf_2
Xplace410 _4335_/A2 VGND VGND VPWR VPWR _5159_/S sky130_fd_sc_hd__buf_2
XFILLER_23_318 VGND VGND VPWR VPWR sky130_fd_sc_hd__decap_3
XFILLER_35_178 VGND VGND VPWR VPWR sky130_fd_sc_hd__decap_3
XFILLER_50_104 VGND VGND VPWR VPWR sky130_fd_sc_hd__decap_3
XFILLER_51_638 VGND VGND VPWR VPWR sky130_fd_sc_hd__decap_3
Xplace465 _4181_/B1 VGND VGND VPWR VPWR _4437_/B1 sky130_fd_sc_hd__buf_2
Xplace454 _4233_/B1 VGND VGND VPWR VPWR _4517_/S sky130_fd_sc_hd__buf_2
Xplace443 _4671_/B VGND VGND VPWR VPWR _4690_/B sky130_fd_sc_hd__buf_2
Xplace432 _5104_/A VGND VGND VPWR VPWR _4791_/A1 sky130_fd_sc_hd__buf_2
X_6740_ _7189_/CLK _6740_/D VGND VGND VPWR VPWR _6740_/Q sky130_fd_sc_hd__dfxtp_2
XFILLER_44_690 VGND VGND VPWR VPWR sky130_fd_sc_hd__decap_3
XFILLER_90_295 VGND VGND VPWR VPWR sky130_fd_sc_hd__decap_3
Xplace487 _3366_/X VGND VGND VPWR VPWR _4339_/B1 sky130_fd_sc_hd__buf_2
Xplace498 _4353_/A2 VGND VGND VPWR VPWR _4433_/B sky130_fd_sc_hd__buf_2
Xplace476 _4471_/S VGND VGND VPWR VPWR _3966_/S sky130_fd_sc_hd__buf_2
X_3952_ _7364_/Q _4495_/A0 _3952_/S VGND VGND VPWR VPWR _7364_/D sky130_fd_sc_hd__mux2_2
XFILLER_31_351 VGND VGND VPWR VPWR sky130_fd_sc_hd__decap_3
X_6671_ _6671_/A VGND VGND VPWR VPWR _6671_/Y sky130_fd_sc_hd__inv_2
X_3883_ _6814_/Q _3913_/A2 _3883_/B1 _6819_/Q VGND VGND VPWR VPWR _3883_/X sky130_fd_sc_hd__a22o_2
XTAP_TAPCELL_ROW_21_519 VGND VPWR sky130_fd_sc_hd__tapvpwrvgnd_1
XFILLER_31_384 VGND VGND VPWR VPWR sky130_fd_sc_hd__decap_3
X_5622_ _5622_/A _5633_/B VGND VGND VPWR VPWR _7017_/D sky130_fd_sc_hd__nor2_2
XFILLER_117_434 VGND VGND VPWR VPWR sky130_fd_sc_hd__decap_3
XFILLER_117_478 VGND VGND VPWR VPWR sky130_fd_sc_hd__fill_1
XFILLER_105_629 VGND VGND VPWR VPWR sky130_fd_sc_hd__decap_3
XFILLER_6_81 VGND VGND VPWR VPWR sky130_fd_sc_hd__decap_3
X_7223_ _7387_/CLK _7223_/D _6503_/Y VGND VGND VPWR VPWR _7223_/Q sky130_fd_sc_hd__dfrtp_2
X_4435_ _7207_/Q _3947_/S _4394_/B _7367_/Q VGND VGND VPWR VPWR _4435_/X sky130_fd_sc_hd__a22o_2
XFILLER_104_139 VGND VGND VPWR VPWR sky130_fd_sc_hd__fill_1
XFILLER_116_27 VGND VGND VPWR VPWR sky130_fd_sc_hd__fill_1
XFILLER_116_38 VGND VGND VPWR VPWR sky130_fd_sc_hd__decap_3
X_7154_ _7355_/CLK _7154_/D _6434_/Y VGND VGND VPWR VPWR _7154_/Q sky130_fd_sc_hd__dfrtp_2
X_4366_ _4460_/A _4364_/Y _4313_/D _4619_/A _4365_/X VGND VGND VPWR VPWR _4366_/X
+ sky130_fd_sc_hd__a32o_2
XFILLER_113_662 VGND VGND VPWR VPWR sky130_fd_sc_hd__decap_3
XFILLER_113_673 VGND VGND VPWR VPWR sky130_fd_sc_hd__decap_3
XFILLER_58_215 VGND VGND VPWR VPWR sky130_fd_sc_hd__decap_3
XFILLER_86_524 VGND VGND VPWR VPWR sky130_fd_sc_hd__decap_3
XFILLER_98_362 VGND VGND VPWR VPWR sky130_fd_sc_hd__fill_2
XFILLER_112_183 VGND VGND VPWR VPWR sky130_fd_sc_hd__decap_3
XFILLER_58_248 VGND VGND VPWR VPWR sky130_fd_sc_hd__decap_3
X_7085_ _7086_/CLK _7085_/D _6365_/Y VGND VGND VPWR VPWR _7085_/Q sky130_fd_sc_hd__dfrtp_2
X_4297_ _5113_/A _4297_/B VGND VGND VPWR VPWR _4297_/Y sky130_fd_sc_hd__nor2_2
XFILLER_100_378 VGND VGND VPWR VPWR sky130_fd_sc_hd__decap_3
XFILLER_73_207 VGND VGND VPWR VPWR sky130_fd_sc_hd__decap_3
XTAP_TAPCELL_ROW_29_619 VGND VPWR sky130_fd_sc_hd__tapvpwrvgnd_1
XFILLER_26_112 VGND VGND VPWR VPWR sky130_fd_sc_hd__decap_3
XFILLER_27_635 VGND VGND VPWR VPWR sky130_fd_sc_hd__decap_3
XFILLER_39_473 VGND VGND VPWR VPWR sky130_fd_sc_hd__decap_3
XFILLER_39_484 VGND VGND VPWR VPWR sky130_fd_sc_hd__decap_3
XFILLER_54_421 VGND VGND VPWR VPWR sky130_fd_sc_hd__decap_3
XFILLER_27_668 VGND VGND VPWR VPWR sky130_fd_sc_hd__decap_3
XFILLER_27_679 VGND VGND VPWR VPWR sky130_fd_sc_hd__decap_3
XFILLER_54_454 VGND VGND VPWR VPWR sky130_fd_sc_hd__decap_3
XTAP_TAPCELL_ROW_1_266 VGND VPWR sky130_fd_sc_hd__tapvpwrvgnd_1
XFILLER_14_307 VGND VGND VPWR VPWR sky130_fd_sc_hd__fill_1
XFILLER_14_318 VGND VGND VPWR VPWR sky130_fd_sc_hd__decap_3
XFILLER_26_167 VGND VGND VPWR VPWR sky130_fd_sc_hd__decap_3
XFILLER_41_104 VGND VGND VPWR VPWR sky130_fd_sc_hd__decap_3
XFILLER_42_627 VGND VGND VPWR VPWR sky130_fd_sc_hd__decap_3
XFILLER_54_498 VGND VGND VPWR VPWR sky130_fd_sc_hd__decap_3
XFILLER_25_57 VGND VGND VPWR VPWR sky130_fd_sc_hd__decap_3
X_6938_ _6943_/CLK _6938_/D VGND VGND VPWR VPWR _6938_/Q sky130_fd_sc_hd__dfxtp_2
XFILLER_50_660 VGND VGND VPWR VPWR sky130_fd_sc_hd__decap_3
X_6869_ clkload8/A _6869_/D VGND VGND VPWR VPWR _6869_/Q sky130_fd_sc_hd__dfxtp_2
XFILLER_10_524 VGND VGND VPWR VPWR sky130_fd_sc_hd__fill_2
XFILLER_50_693 VGND VGND VPWR VPWR sky130_fd_sc_hd__decap_3
XFILLER_10_557 VGND VGND VPWR VPWR sky130_fd_sc_hd__decap_3
XFILLER_6_539 VGND VGND VPWR VPWR sky130_fd_sc_hd__decap_3
XFILLER_2_701 VGND VGND VPWR VPWR sky130_fd_sc_hd__decap_3
XFILLER_104_640 VGND VGND VPWR VPWR sky130_fd_sc_hd__decap_3
XFILLER_104_651 VGND VGND VPWR VPWR sky130_fd_sc_hd__decap_3
XFILLER_1_233 VGND VGND VPWR VPWR sky130_fd_sc_hd__decap_3
XFILLER_89_340 VGND VGND VPWR VPWR sky130_fd_sc_hd__fill_2
XTAP_TAPCELL_ROW_9_366 VGND VPWR sky130_fd_sc_hd__tapvpwrvgnd_1
XFILLER_9_3 VGND VGND VPWR VPWR sky130_fd_sc_hd__decap_3
XFILLER_104_684 VGND VGND VPWR VPWR sky130_fd_sc_hd__decap_3
XFILLER_1_255 VGND VGND VPWR VPWR sky130_fd_sc_hd__fill_2
XFILLER_49_204 VGND VGND VPWR VPWR sky130_fd_sc_hd__decap_3
XFILLER_77_502 VGND VGND VPWR VPWR sky130_fd_sc_hd__fill_2
XFILLER_49_237 VGND VGND VPWR VPWR sky130_fd_sc_hd__fill_2
XFILLER_77_557 VGND VGND VPWR VPWR sky130_fd_sc_hd__decap_3
XFILLER_64_207 VGND VGND VPWR VPWR sky130_fd_sc_hd__decap_3
XFILLER_18_613 VGND VGND VPWR VPWR sky130_fd_sc_hd__decap_3
XFILLER_66_64 VGND VGND VPWR VPWR sky130_fd_sc_hd__decap_3
XFILLER_66_97 VGND VGND VPWR VPWR sky130_fd_sc_hd__fill_2
XFILLER_92_527 VGND VGND VPWR VPWR sky130_fd_sc_hd__decap_3
XFILLER_18_657 VGND VGND VPWR VPWR sky130_fd_sc_hd__decap_3
Xhold1280 _7125_/Q VGND VGND VPWR VPWR _5417_/A0 sky130_fd_sc_hd__dlygate4sd3_1
Xhold1291 _7143_/Q VGND VGND VPWR VPWR _5379_/A0 sky130_fd_sc_hd__dlygate4sd3_1
XTAP_TAPCELL_ROW_86_1333 VGND VPWR sky130_fd_sc_hd__tapvpwrvgnd_1
XFILLER_17_178 VGND VGND VPWR VPWR sky130_fd_sc_hd__decap_3
XFILLER_45_487 VGND VGND VPWR VPWR sky130_fd_sc_hd__fill_1
XFILLER_60_402 VGND VGND VPWR VPWR sky130_fd_sc_hd__decap_3
XFILLER_72_273 VGND VGND VPWR VPWR sky130_fd_sc_hd__decap_3
XTAP_TAPCELL_ROW_56_961 VGND VPWR sky130_fd_sc_hd__tapvpwrvgnd_1
XFILLER_26_690 VGND VGND VPWR VPWR sky130_fd_sc_hd__decap_3
XFILLER_32_137 VGND VGND VPWR VPWR sky130_fd_sc_hd__decap_3
XFILLER_33_638 VGND VGND VPWR VPWR sky130_fd_sc_hd__decap_3
XFILLER_60_435 VGND VGND VPWR VPWR sky130_fd_sc_hd__decap_3
XFILLER_13_340 VGND VGND VPWR VPWR sky130_fd_sc_hd__decap_3
XFILLER_82_85 VGND VGND VPWR VPWR sky130_fd_sc_hd__decap_3
XFILLER_13_373 VGND VGND VPWR VPWR sky130_fd_sc_hd__decap_3
XFILLER_41_671 VGND VGND VPWR VPWR sky130_fd_sc_hd__fill_1
XFILLER_41_682 VGND VGND VPWR VPWR sky130_fd_sc_hd__decap_3
XFILLER_9_311 VGND VGND VPWR VPWR sky130_fd_sc_hd__decap_3
XFILLER_40_181 VGND VGND VPWR VPWR sky130_fd_sc_hd__decap_3
XFILLER_9_377 VGND VGND VPWR VPWR sky130_fd_sc_hd__decap_3
XFILLER_9_399 VGND VGND VPWR VPWR sky130_fd_sc_hd__decap_3
XTAP_TAPCELL_ROW_97_1473 VGND VPWR sky130_fd_sc_hd__tapvpwrvgnd_1
XFILLER_5_561 VGND VGND VPWR VPWR sky130_fd_sc_hd__decap_3
XFILLER_114_437 VGND VGND VPWR VPWR sky130_fd_sc_hd__decap_3
XFILLER_5_594 VGND VGND VPWR VPWR sky130_fd_sc_hd__decap_3
X_4220_ _7196_/Q _3966_/S _4354_/B1 _7388_/Q VGND VGND VPWR VPWR _4220_/X sky130_fd_sc_hd__a22o_2
XFILLER_99_148 VGND VGND VPWR VPWR sky130_fd_sc_hd__decap_3
XFILLER_68_502 VGND VGND VPWR VPWR sky130_fd_sc_hd__decap_3
XFILLER_110_610 VGND VGND VPWR VPWR sky130_fd_sc_hd__decap_3
XFILLER_110_643 VGND VGND VPWR VPWR sky130_fd_sc_hd__fill_1
XFILLER_68_524 VGND VGND VPWR VPWR sky130_fd_sc_hd__decap_3
X_4151_ _7019_/Q _4437_/A2 _3947_/S _7202_/Q _4150_/X VGND VGND VPWR VPWR _4151_/X
+ sky130_fd_sc_hd__a221o_2
XFILLER_110_654 VGND VGND VPWR VPWR sky130_fd_sc_hd__decap_3
XFILLER_83_505 VGND VGND VPWR VPWR sky130_fd_sc_hd__fill_1
XFILLER_95_343 VGND VGND VPWR VPWR sky130_fd_sc_hd__fill_1
XFILLER_95_365 VGND VGND VPWR VPWR sky130_fd_sc_hd__decap_3
X_4082_ _4082_/A _4068_/A VGND VGND VPWR VPWR _4082_/X sky130_fd_sc_hd__or2b_2
XFILLER_110_687 VGND VGND VPWR VPWR sky130_fd_sc_hd__decap_3
XFILLER_55_218 VGND VGND VPWR VPWR sky130_fd_sc_hd__decap_3
XFILLER_36_421 VGND VGND VPWR VPWR sky130_fd_sc_hd__decap_3
XFILLER_36_454 VGND VGND VPWR VPWR sky130_fd_sc_hd__decap_3
XFILLER_102_29 VGND VGND VPWR VPWR sky130_fd_sc_hd__decap_3
XFILLER_23_104 VGND VGND VPWR VPWR sky130_fd_sc_hd__decap_3
XFILLER_24_616 VGND VGND VPWR VPWR sky130_fd_sc_hd__decap_3
XFILLER_36_487 VGND VGND VPWR VPWR sky130_fd_sc_hd__fill_1
XFILLER_63_240 VGND VGND VPWR VPWR sky130_fd_sc_hd__decap_3
XFILLER_63_262 VGND VGND VPWR VPWR sky130_fd_sc_hd__decap_3
XFILLER_23_137 VGND VGND VPWR VPWR sky130_fd_sc_hd__decap_3
X_4984_ _5099_/A _4619_/Y _4624_/A VGND VGND VPWR VPWR _5031_/B sky130_fd_sc_hd__a21o_2
XTAP_TAPCELL_ROW_106_1580 VGND VPWR sky130_fd_sc_hd__tapvpwrvgnd_1
XFILLER_32_660 VGND VGND VPWR VPWR sky130_fd_sc_hd__decap_3
XFILLER_51_457 VGND VGND VPWR VPWR sky130_fd_sc_hd__decap_3
X_6723_ clkload6/A _6723_/D VGND VGND VPWR VPWR _6723_/Q sky130_fd_sc_hd__dfxtp_2
X_3935_ _7372_/Q _7340_/Q _3945_/S VGND VGND VPWR VPWR _7372_/D sky130_fd_sc_hd__mux2_2
XTAP_TAPCELL_ROW_34_677 VGND VPWR sky130_fd_sc_hd__tapvpwrvgnd_1
XFILLER_32_693 VGND VGND VPWR VPWR sky130_fd_sc_hd__decap_3
X_6654_ _6654_/A VGND VGND VPWR VPWR _6654_/Y sky130_fd_sc_hd__inv_2
XTAP_TAPCELL_ROW_34_688 VGND VPWR sky130_fd_sc_hd__tapvpwrvgnd_1
XFILLER_31_181 VGND VGND VPWR VPWR sky130_fd_sc_hd__decap_3
X_5605_ _5605_/A _5633_/B VGND VGND VPWR VPWR _7025_/D sky130_fd_sc_hd__or2_2
X_3866_ _6696_/Q _6786_/Q _6874_/Q _6922_/Q _3991_/B _3661_/B VGND VGND VPWR VPWR
+ _3866_/X sky130_fd_sc_hd__mux4_2
X_6585_ _6647_/A VGND VGND VPWR VPWR _6585_/Y sky130_fd_sc_hd__inv_2
X_3797_ _6750_/Q _3892_/A2 _3890_/B1 _6732_/Q VGND VGND VPWR VPWR _3797_/X sky130_fd_sc_hd__a22o_2
XFILLER_117_264 VGND VGND VPWR VPWR sky130_fd_sc_hd__decap_3
XFILLER_105_437 VGND VGND VPWR VPWR sky130_fd_sc_hd__decap_3
X_7206_ _7400_/CLK _7206_/D _6486_/Y VGND VGND VPWR VPWR _7206_/Q sky130_fd_sc_hd__dfrtp_2
Xoutput652 _7006_/Q VGND VGND VPWR VPWR pc_out[29] sky130_fd_sc_hd__clkdlybuf4s25_1
Xoutput641 _6996_/Q VGND VGND VPWR VPWR pc_out[19] sky130_fd_sc_hd__clkdlybuf4s25_1
Xoutput630 _5646_/Y VGND VGND VPWR VPWR instruction_out[9] sky130_fd_sc_hd__clkdlybuf4s25_1
X_4418_ _7023_/Q _4422_/A2 _4417_/X VGND VGND VPWR VPWR _4425_/C sky130_fd_sc_hd__a21o_2
XFILLER_59_502 VGND VGND VPWR VPWR sky130_fd_sc_hd__fill_2
X_5398_ _5398_/A0 _4997_/X _5402_/S VGND VGND VPWR VPWR _7134_/D sky130_fd_sc_hd__mux2_2
XFILLER_99_682 VGND VGND VPWR VPWR sky130_fd_sc_hd__decap_3
XFILLER_99_671 VGND VGND VPWR VPWR sky130_fd_sc_hd__fill_1
XFILLER_101_632 VGND VGND VPWR VPWR sky130_fd_sc_hd__decap_3
XFILLER_113_481 VGND VGND VPWR VPWR sky130_fd_sc_hd__fill_2
XFILLER_86_332 VGND VGND VPWR VPWR sky130_fd_sc_hd__fill_1
X_7137_ _7362_/CLK _7137_/D _6417_/Y VGND VGND VPWR VPWR _7137_/Q sky130_fd_sc_hd__dfrtp_2
X_4349_ _7257_/Q _4356_/A2 _4349_/B1 _7225_/Q _4348_/X VGND VGND VPWR VPWR _4367_/A
+ sky130_fd_sc_hd__a221o_2
XTAP_TAPCELL_ROW_70_1134 VGND VPWR sky130_fd_sc_hd__tapvpwrvgnd_1
XTAP_TAPCELL_ROW_6_336 VGND VPWR sky130_fd_sc_hd__tapvpwrvgnd_1
XFILLER_100_131 VGND VGND VPWR VPWR sky130_fd_sc_hd__decap_3
XFILLER_101_665 VGND VGND VPWR VPWR sky130_fd_sc_hd__decap_3
XFILLER_101_676 VGND VGND VPWR VPWR sky130_fd_sc_hd__decap_3
XFILLER_59_557 VGND VGND VPWR VPWR sky130_fd_sc_hd__decap_3
XFILLER_86_365 VGND VGND VPWR VPWR sky130_fd_sc_hd__decap_3
X_7068_ _7390_/CLK _7068_/D _6348_/Y VGND VGND VPWR VPWR _7068_/Q sky130_fd_sc_hd__dfrtp_2
XFILLER_100_153 VGND VGND VPWR VPWR sky130_fd_sc_hd__decap_3
XFILLER_39_270 VGND VGND VPWR VPWR sky130_fd_sc_hd__fill_1
XFILLER_46_229 VGND VGND VPWR VPWR sky130_fd_sc_hd__decap_3
XFILLER_74_549 VGND VGND VPWR VPWR sky130_fd_sc_hd__decap_3
XFILLER_100_197 VGND VGND VPWR VPWR sky130_fd_sc_hd__decap_3
XFILLER_15_605 VGND VGND VPWR VPWR sky130_fd_sc_hd__decap_3
XFILLER_27_487 VGND VGND VPWR VPWR sky130_fd_sc_hd__decap_3
XFILLER_14_115 VGND VGND VPWR VPWR sky130_fd_sc_hd__decap_3
XFILLER_15_638 VGND VGND VPWR VPWR sky130_fd_sc_hd__decap_3
XFILLER_42_435 VGND VGND VPWR VPWR sky130_fd_sc_hd__decap_3
XFILLER_82_582 VGND VGND VPWR VPWR sky130_fd_sc_hd__fill_1
XTAP_TAPCELL_ROW_53_920 VGND VPWR sky130_fd_sc_hd__tapvpwrvgnd_1
XFILLER_14_159 VGND VGND VPWR VPWR sky130_fd_sc_hd__decap_3
XFILLER_30_619 VGND VGND VPWR VPWR sky130_fd_sc_hd__decap_3
XFILLER_23_671 VGND VGND VPWR VPWR sky130_fd_sc_hd__fill_1
XFILLER_23_682 VGND VGND VPWR VPWR sky130_fd_sc_hd__decap_3
XTAP_TAPCELL_ROW_81_1274 VGND VPWR sky130_fd_sc_hd__tapvpwrvgnd_1
XFILLER_10_343 VGND VGND VPWR VPWR sky130_fd_sc_hd__decap_3
XFILLER_52_88 VGND VGND VPWR VPWR sky130_fd_sc_hd__fill_2
XFILLER_10_365 VGND VGND VPWR VPWR sky130_fd_sc_hd__decap_3
XFILLER_108_242 VGND VGND VPWR VPWR sky130_fd_sc_hd__decap_3
XFILLER_108_253 VGND VGND VPWR VPWR sky130_fd_sc_hd__decap_3
XFILLER_6_336 VGND VGND VPWR VPWR sky130_fd_sc_hd__decap_3
XFILLER_6_358 VGND VGND VPWR VPWR sky130_fd_sc_hd__decap_3
XFILLER_2_531 VGND VGND VPWR VPWR sky130_fd_sc_hd__fill_1
XFILLER_2_542 VGND VGND VPWR VPWR sky130_fd_sc_hd__decap_3
XFILLER_97_608 VGND VGND VPWR VPWR sky130_fd_sc_hd__decap_3
XFILLER_117_81 VGND VGND VPWR VPWR sky130_fd_sc_hd__decap_3
XFILLER_104_492 VGND VGND VPWR VPWR sky130_fd_sc_hd__decap_3
XFILLER_77_52 VGND VGND VPWR VPWR sky130_fd_sc_hd__decap_3
XFILLER_77_63 VGND VGND VPWR VPWR sky130_fd_sc_hd__decap_3
XFILLER_89_181 VGND VGND VPWR VPWR sky130_fd_sc_hd__decap_3
XFILLER_65_505 VGND VGND VPWR VPWR sky130_fd_sc_hd__decap_3
XFILLER_77_343 VGND VGND VPWR VPWR sky130_fd_sc_hd__decap_3
XFILLER_77_85 VGND VGND VPWR VPWR sky130_fd_sc_hd__decap_3
XFILLER_18_410 VGND VGND VPWR VPWR sky130_fd_sc_hd__decap_3
XFILLER_37_218 VGND VGND VPWR VPWR sky130_fd_sc_hd__decap_3
XFILLER_92_324 VGND VGND VPWR VPWR sky130_fd_sc_hd__fill_1
XFILLER_18_421 VGND VGND VPWR VPWR sky130_fd_sc_hd__decap_3
XFILLER_92_335 VGND VGND VPWR VPWR sky130_fd_sc_hd__decap_3
XFILLER_93_51 VGND VGND VPWR VPWR sky130_fd_sc_hd__decap_3
XFILLER_18_465 VGND VGND VPWR VPWR sky130_fd_sc_hd__fill_1
XFILLER_61_700 VGND VGND VPWR VPWR sky130_fd_sc_hd__decap_3
XFILLER_92_368 VGND VGND VPWR VPWR sky130_fd_sc_hd__fill_1
XFILLER_92_379 VGND VGND VPWR VPWR sky130_fd_sc_hd__decap_3
XFILLER_73_582 VGND VGND VPWR VPWR sky130_fd_sc_hd__decap_3
XFILLER_14_660 VGND VGND VPWR VPWR sky130_fd_sc_hd__decap_3
XFILLER_14_693 VGND VGND VPWR VPWR sky130_fd_sc_hd__decap_3
X_3720_ _6911_/Q _3906_/A2 _3911_/B1 _6903_/Q VGND VGND VPWR VPWR _3720_/X sky130_fd_sc_hd__a22o_2
XFILLER_13_181 VGND VGND VPWR VPWR sky130_fd_sc_hd__decap_3
Xclkbuf_leaf_40_clk clkbuf_leaf_1_clk/A VGND VGND VPWR VPWR clkload4/A sky130_fd_sc_hd__clkbuf_16
XTAP_TAPCELL_ROW_31_647 VGND VPWR sky130_fd_sc_hd__tapvpwrvgnd_1
XFILLER_9_130 VGND VGND VPWR VPWR sky130_fd_sc_hd__fill_1
X_3651_ _3665_/A _3665_/B VGND VGND VPWR VPWR _3651_/Y sky130_fd_sc_hd__nor2_2
XFILLER_61_3 VGND VGND VPWR VPWR sky130_fd_sc_hd__decap_3
X_6370_ _6571_/A VGND VGND VPWR VPWR _6370_/Y sky130_fd_sc_hd__inv_2
X_3582_ _7348_/Q _3449_/X _3407_/X _7124_/Q VGND VGND VPWR VPWR _3583_/C sky130_fd_sc_hd__a22o_2
X_5321_ _5321_/A0 _4932_/X _5323_/S VGND VGND VPWR VPWR _7170_/D sky130_fd_sc_hd__mux2_2
XTAP_TAPCELL_ROW_11_393 VGND VPWR sky130_fd_sc_hd__tapvpwrvgnd_1
XFILLER_88_608 VGND VGND VPWR VPWR sky130_fd_sc_hd__fill_1
XFILLER_102_418 VGND VGND VPWR VPWR sky130_fd_sc_hd__fill_2
XFILLER_102_429 VGND VGND VPWR VPWR sky130_fd_sc_hd__decap_3
X_4203_ _4203_/A _4203_/B _4203_/C VGND VGND VPWR VPWR _4203_/X sky130_fd_sc_hd__and3_2
XFILLER_110_440 VGND VGND VPWR VPWR sky130_fd_sc_hd__fill_2
XFILLER_68_365 VGND VGND VPWR VPWR sky130_fd_sc_hd__decap_3
XFILLER_95_140 VGND VGND VPWR VPWR sky130_fd_sc_hd__decap_3
XFILLER_96_663 VGND VGND VPWR VPWR sky130_fd_sc_hd__decap_3
X_4134_ _7020_/Q _4437_/A2 _3947_/S _7203_/Q _4133_/X VGND VGND VPWR VPWR _4134_/X
+ sky130_fd_sc_hd__a221o_2
XFILLER_28_218 VGND VGND VPWR VPWR sky130_fd_sc_hd__decap_3
XFILLER_96_696 VGND VGND VPWR VPWR sky130_fd_sc_hd__decap_3
X_4065_ _7052_/Q _4488_/S _4181_/B1 _7404_/Q _4064_/X VGND VGND VPWR VPWR _4065_/X
+ sky130_fd_sc_hd__a221o_2
XTAP_TAPCELL_ROW_39_747 VGND VPWR sky130_fd_sc_hd__tapvpwrvgnd_1
XFILLER_36_240 VGND VGND VPWR VPWR sky130_fd_sc_hd__decap_3
XFILLER_36_262 VGND VGND VPWR VPWR sky130_fd_sc_hd__decap_3
XFILLER_24_435 VGND VGND VPWR VPWR sky130_fd_sc_hd__decap_3
XFILLER_91_390 VGND VGND VPWR VPWR sky130_fd_sc_hd__fill_2
XFILLER_12_619 VGND VGND VPWR VPWR sky130_fd_sc_hd__decap_3
XFILLER_24_446 VGND VGND VPWR VPWR sky130_fd_sc_hd__decap_3
XFILLER_24_457 VGND VGND VPWR VPWR sky130_fd_sc_hd__decap_3
XFILLER_51_243 VGND VGND VPWR VPWR sky130_fd_sc_hd__decap_3
XTAP_TAPCELL_ROW_19_493 VGND VPWR sky130_fd_sc_hd__tapvpwrvgnd_1
XFILLER_11_129 VGND VGND VPWR VPWR sky130_fd_sc_hd__decap_3
XFILLER_51_276 VGND VGND VPWR VPWR sky130_fd_sc_hd__decap_3
XFILLER_51_287 VGND VGND VPWR VPWR sky130_fd_sc_hd__decap_3
X_4967_ _4967_/A _4967_/B VGND VGND VPWR VPWR _4967_/X sky130_fd_sc_hd__or2_2
Xclkbuf_leaf_31_clk clkload0/A VGND VGND VPWR VPWR _7355_/CLK sky130_fd_sc_hd__clkbuf_16
X_6706_ _6944_/CLK _6706_/D VGND VGND VPWR VPWR _6706_/Q sky130_fd_sc_hd__dfxtp_2
X_4898_ _4799_/A _3756_/X _4897_/X _5010_/A VGND VGND VPWR VPWR _4898_/X sky130_fd_sc_hd__a211o_2
X_3918_ _6915_/Q _3921_/A2 _3922_/A2 _6779_/Q _3917_/X VGND VGND VPWR VPWR _3918_/X
+ sky130_fd_sc_hd__a221o_2
XFILLER_20_663 VGND VGND VPWR VPWR sky130_fd_sc_hd__decap_3
X_6637_ _6637_/A VGND VGND VPWR VPWR _6637_/Y sky130_fd_sc_hd__inv_2
X_3849_ _6859_/Q _3886_/B1 _3887_/B1 _6899_/Q _3848_/X VGND VGND VPWR VPWR _3849_/X
+ sky130_fd_sc_hd__a221o_2
XFILLER_118_551 VGND VGND VPWR VPWR sky130_fd_sc_hd__decap_3
XFILLER_20_696 VGND VGND VPWR VPWR sky130_fd_sc_hd__decap_3
X_6568_ _6571_/A VGND VGND VPWR VPWR _6568_/Y sky130_fd_sc_hd__inv_2
XTAP_TAPCELL_ROW_119_1760 VGND VPWR sky130_fd_sc_hd__tapvpwrvgnd_1
XFILLER_106_713 VGND VGND VPWR VPWR sky130_fd_sc_hd__fill_1
XFILLER_118_584 VGND VGND VPWR VPWR sky130_fd_sc_hd__decap_3
XFILLER_3_306 VGND VGND VPWR VPWR sky130_fd_sc_hd__fill_2
XFILLER_105_234 VGND VGND VPWR VPWR sky130_fd_sc_hd__decap_3
XFILLER_118_595 VGND VGND VPWR VPWR sky130_fd_sc_hd__decap_3
XFILLER_3_328 VGND VGND VPWR VPWR sky130_fd_sc_hd__decap_3
X_6499_ _6598_/A VGND VGND VPWR VPWR _6499_/Y sky130_fd_sc_hd__inv_2
XFILLER_105_245 VGND VGND VPWR VPWR sky130_fd_sc_hd__decap_3
XFILLER_78_118 VGND VGND VPWR VPWR sky130_fd_sc_hd__decap_3
XFILLER_87_652 VGND VGND VPWR VPWR sky130_fd_sc_hd__decap_3
XFILLER_47_55 VGND VGND VPWR VPWR sky130_fd_sc_hd__fill_1
XFILLER_86_162 VGND VGND VPWR VPWR sky130_fd_sc_hd__decap_3
XFILLER_87_685 VGND VGND VPWR VPWR sky130_fd_sc_hd__decap_3
XFILLER_15_402 VGND VGND VPWR VPWR sky130_fd_sc_hd__fill_1
XFILLER_27_240 VGND VGND VPWR VPWR sky130_fd_sc_hd__decap_3
XFILLER_43_700 VGND VGND VPWR VPWR sky130_fd_sc_hd__decap_3
XFILLER_103_72 VGND VGND VPWR VPWR sky130_fd_sc_hd__decap_3
XFILLER_103_94 VGND VGND VPWR VPWR sky130_fd_sc_hd__decap_3
XFILLER_27_273 VGND VGND VPWR VPWR sky130_fd_sc_hd__decap_3
XFILLER_27_284 VGND VGND VPWR VPWR sky130_fd_sc_hd__decap_3
XFILLER_42_221 VGND VGND VPWR VPWR sky130_fd_sc_hd__fill_2
XFILLER_15_446 VGND VGND VPWR VPWR sky130_fd_sc_hd__fill_2
XFILLER_63_54 VGND VGND VPWR VPWR sky130_fd_sc_hd__fill_2
XFILLER_15_479 VGND VGND VPWR VPWR sky130_fd_sc_hd__decap_3
XFILLER_30_416 VGND VGND VPWR VPWR sky130_fd_sc_hd__fill_1
XFILLER_30_427 VGND VGND VPWR VPWR sky130_fd_sc_hd__decap_3
XFILLER_42_265 VGND VGND VPWR VPWR sky130_fd_sc_hd__decap_3
XFILLER_42_287 VGND VGND VPWR VPWR sky130_fd_sc_hd__decap_3
XFILLER_11_641 VGND VGND VPWR VPWR sky130_fd_sc_hd__decap_3
Xclkbuf_leaf_22_clk clkload2/A VGND VGND VPWR VPWR _7342_/CLK sky130_fd_sc_hd__clkbuf_16
XFILLER_11_685 VGND VGND VPWR VPWR sky130_fd_sc_hd__decap_3
XFILLER_7_612 VGND VGND VPWR VPWR sky130_fd_sc_hd__decap_3
XFILLER_7_623 VGND VGND VPWR VPWR sky130_fd_sc_hd__decap_3
XFILLER_109_551 VGND VGND VPWR VPWR sky130_fd_sc_hd__decap_3
XFILLER_6_144 VGND VGND VPWR VPWR sky130_fd_sc_hd__decap_3
XFILLER_7_656 VGND VGND VPWR VPWR sky130_fd_sc_hd__decap_3
XTAP_TAPCELL_ROW_94_1432 VGND VPWR sky130_fd_sc_hd__tapvpwrvgnd_1
XFILLER_2_350 VGND VGND VPWR VPWR sky130_fd_sc_hd__decap_3
XFILLER_88_73 VGND VGND VPWR VPWR sky130_fd_sc_hd__decap_3
XFILLER_97_449 VGND VGND VPWR VPWR sky130_fd_sc_hd__decap_3
XFILLER_111_259 VGND VGND VPWR VPWR sky130_fd_sc_hd__decap_3
XFILLER_78_641 VGND VGND VPWR VPWR sky130_fd_sc_hd__decap_3
XFILLER_78_663 VGND VGND VPWR VPWR sky130_fd_sc_hd__decap_3
XFILLER_78_696 VGND VGND VPWR VPWR sky130_fd_sc_hd__decap_3
XPHY_EDGE_ROW_108_Left_228 VGND VGND VPWR VPWR sky130_fd_sc_hd__decap_3
XFILLER_92_121 VGND VGND VPWR VPWR sky130_fd_sc_hd__decap_3
XFILLER_93_644 VGND VGND VPWR VPWR sky130_fd_sc_hd__decap_3
XFILLER_92_165 VGND VGND VPWR VPWR sky130_fd_sc_hd__decap_3
XFILLER_93_688 VGND VGND VPWR VPWR sky130_fd_sc_hd__decap_3
XTAP_TAPCELL_ROW_36_706 VGND VPWR sky130_fd_sc_hd__tapvpwrvgnd_1
XFILLER_18_284 VGND VGND VPWR VPWR sky130_fd_sc_hd__decap_3
XFILLER_33_210 VGND VGND VPWR VPWR sky130_fd_sc_hd__decap_3
XFILLER_80_327 VGND VGND VPWR VPWR sky130_fd_sc_hd__decap_3
XFILLER_33_254 VGND VGND VPWR VPWR sky130_fd_sc_hd__decap_3
X_4821_ _4799_/A _3704_/X _4819_/X _5010_/A VGND VGND VPWR VPWR _4821_/X sky130_fd_sc_hd__a211o_2
XFILLER_33_287 VGND VGND VPWR VPWR sky130_fd_sc_hd__decap_3
XFILLER_61_596 VGND VGND VPWR VPWR sky130_fd_sc_hd__decap_3
XTAP_TAPCELL_ROW_16_463 VGND VPWR sky130_fd_sc_hd__tapvpwrvgnd_1
XTAP_TAPCELL_ROW_16_452 VGND VPWR sky130_fd_sc_hd__tapvpwrvgnd_1
XTAP_TAPCELL_ROW_103_1550 VGND VPWR sky130_fd_sc_hd__tapvpwrvgnd_1
XFILLER_21_449 VGND VGND VPWR VPWR sky130_fd_sc_hd__decap_3
Xclkbuf_leaf_13_clk clkload1/A VGND VGND VPWR VPWR _7402_/CLK sky130_fd_sc_hd__clkbuf_16
X_4752_ _5666_/A _7006_/D _4751_/Y VGND VGND VPWR VPWR _4752_/X sky130_fd_sc_hd__a21o_2
XPHY_EDGE_ROW_117_Left_237 VGND VGND VPWR VPWR sky130_fd_sc_hd__decap_3
XFILLER_119_337 VGND VGND VPWR VPWR sky130_fd_sc_hd__decap_3
X_4683_ _6997_/Q _6998_/Q _4690_/B VGND VGND VPWR VPWR _4683_/X sky130_fd_sc_hd__o21a_2
X_3703_ _6938_/Q _3760_/A2 _3759_/A2 _6802_/Q VGND VGND VPWR VPWR _3703_/X sky130_fd_sc_hd__a22o_2
X_6422_ _6648_/A VGND VGND VPWR VPWR _6422_/Y sky130_fd_sc_hd__inv_2
X_3634_ _3636_/B _3631_/Y _3632_/X _3633_/Y VGND VGND VPWR VPWR _3634_/Y sky130_fd_sc_hd__o211ai_4
X_6353_ _6677_/A VGND VGND VPWR VPWR _6353_/Y sky130_fd_sc_hd__inv_2
X_3565_ _3469_/A _3469_/B _3564_/X _3449_/A VGND VGND VPWR VPWR _5648_/B sky130_fd_sc_hd__o211a_2
XFILLER_0_309 VGND VGND VPWR VPWR sky130_fd_sc_hd__decap_3
XFILLER_115_554 VGND VGND VPWR VPWR sky130_fd_sc_hd__decap_3
XFILLER_88_416 VGND VGND VPWR VPWR sky130_fd_sc_hd__decap_3
X_6284_ _6288_/A VGND VGND VPWR VPWR _6284_/Y sky130_fd_sc_hd__inv_2
X_5304_ _5304_/A0 _4792_/X _5315_/S VGND VGND VPWR VPWR _7178_/D sky130_fd_sc_hd__mux2_2
X_3496_ _7215_/Q _3318_/B _5159_/S _7279_/Q _3495_/X VGND VGND VPWR VPWR _3496_/X
+ sky130_fd_sc_hd__a221o_2
XFILLER_115_587 VGND VGND VPWR VPWR sky130_fd_sc_hd__decap_3
XFILLER_88_427 VGND VGND VPWR VPWR sky130_fd_sc_hd__decap_3
XFILLER_102_259 VGND VGND VPWR VPWR sky130_fd_sc_hd__decap_3
XFILLER_69_641 VGND VGND VPWR VPWR sky130_fd_sc_hd__decap_3
XFILLER_29_505 VGND VGND VPWR VPWR sky130_fd_sc_hd__decap_3
XFILLER_56_302 VGND VGND VPWR VPWR sky130_fd_sc_hd__decap_3
XFILLER_68_162 VGND VGND VPWR VPWR sky130_fd_sc_hd__decap_3
XFILLER_69_685 VGND VGND VPWR VPWR sky130_fd_sc_hd__decap_3
XFILLER_84_622 VGND VGND VPWR VPWR sky130_fd_sc_hd__decap_3
XFILLER_96_460 VGND VGND VPWR VPWR sky130_fd_sc_hd__decap_3
XFILLER_29_538 VGND VGND VPWR VPWR sky130_fd_sc_hd__fill_1
X_5097_ _6985_/Q _5120_/A VGND VGND VPWR VPWR _5098_/B sky130_fd_sc_hd__nor2_2
X_4117_ _4205_/A _4117_/B _4117_/C VGND VGND VPWR VPWR _4117_/Y sky130_fd_sc_hd__nand3_2
XFILLER_25_700 VGND VGND VPWR VPWR sky130_fd_sc_hd__decap_3
XFILLER_44_508 VGND VGND VPWR VPWR sky130_fd_sc_hd__decap_3
XFILLER_84_666 VGND VGND VPWR VPWR sky130_fd_sc_hd__decap_3
XFILLER_84_699 VGND VGND VPWR VPWR sky130_fd_sc_hd__fill_1
X_4048_ _7117_/Q _4434_/A2 _4434_/B1 _7149_/Q VGND VGND VPWR VPWR _4048_/X sky130_fd_sc_hd__a22o_2
XFILLER_37_593 VGND VGND VPWR VPWR sky130_fd_sc_hd__decap_3
XFILLER_83_187 VGND VGND VPWR VPWR sky130_fd_sc_hd__decap_3
XFILLER_24_221 VGND VGND VPWR VPWR sky130_fd_sc_hd__decap_3
XFILLER_52_530 VGND VGND VPWR VPWR sky130_fd_sc_hd__fill_2
XFILLER_12_405 VGND VGND VPWR VPWR sky130_fd_sc_hd__decap_3
XFILLER_12_416 VGND VGND VPWR VPWR sky130_fd_sc_hd__decap_3
XTAP_TAPCELL_ROW_65_1066 VGND VPWR sky130_fd_sc_hd__tapvpwrvgnd_1
XFILLER_33_46 VGND VGND VPWR VPWR sky130_fd_sc_hd__fill_2
XTAP_TAPCELL_ROW_117_1719 VGND VPWR sky130_fd_sc_hd__tapvpwrvgnd_1
XFILLER_4_626 VGND VGND VPWR VPWR sky130_fd_sc_hd__decap_3
XFILLER_109_3 VGND VGND VPWR VPWR sky130_fd_sc_hd__decap_3
XFILLER_4_648 VGND VGND VPWR VPWR sky130_fd_sc_hd__decap_3
XFILLER_106_587 VGND VGND VPWR VPWR sky130_fd_sc_hd__fill_1
XFILLER_106_598 VGND VGND VPWR VPWR sky130_fd_sc_hd__decap_3
XFILLER_79_449 VGND VGND VPWR VPWR sky130_fd_sc_hd__decap_3
XFILLER_58_32 VGND VGND VPWR VPWR sky130_fd_sc_hd__decap_3
XFILLER_58_65 VGND VGND VPWR VPWR sky130_fd_sc_hd__fill_1
XFILLER_47_313 VGND VGND VPWR VPWR sky130_fd_sc_hd__decap_3
XFILLER_59_140 VGND VGND VPWR VPWR sky130_fd_sc_hd__decap_3
XFILLER_101_270 VGND VGND VPWR VPWR sky130_fd_sc_hd__decap_3
XFILLER_101_281 VGND VGND VPWR VPWR sky130_fd_sc_hd__decap_3
XFILLER_101_292 VGND VGND VPWR VPWR sky130_fd_sc_hd__decap_3
XFILLER_74_121 VGND VGND VPWR VPWR sky130_fd_sc_hd__decap_3
XFILLER_75_644 VGND VGND VPWR VPWR sky130_fd_sc_hd__decap_3
XFILLER_114_71 VGND VGND VPWR VPWR sky130_fd_sc_hd__decap_3
XFILLER_74_165 VGND VGND VPWR VPWR sky130_fd_sc_hd__decap_3
XFILLER_75_688 VGND VGND VPWR VPWR sky130_fd_sc_hd__decap_3
XFILLER_62_349 VGND VGND VPWR VPWR sky130_fd_sc_hd__fill_2
XFILLER_74_53 VGND VGND VPWR VPWR sky130_fd_sc_hd__decap_3
XFILLER_90_625 VGND VGND VPWR VPWR sky130_fd_sc_hd__decap_3
XFILLER_31_703 VGND VGND VPWR VPWR sky130_fd_sc_hd__decap_3
XFILLER_55_390 VGND VGND VPWR VPWR sky130_fd_sc_hd__fill_2
XFILLER_74_97 VGND VGND VPWR VPWR sky130_fd_sc_hd__decap_3
XFILLER_90_669 VGND VGND VPWR VPWR sky130_fd_sc_hd__decap_3
XFILLER_15_287 VGND VGND VPWR VPWR sky130_fd_sc_hd__decap_3
XFILLER_30_235 VGND VGND VPWR VPWR sky130_fd_sc_hd__decap_3
XFILLER_90_41 VGND VGND VPWR VPWR sky130_fd_sc_hd__fill_1
XTAP_TAPCELL_ROW_13_422 VGND VPWR sky130_fd_sc_hd__tapvpwrvgnd_1
XFILLER_90_85 VGND VGND VPWR VPWR sky130_fd_sc_hd__decap_3
XTAP_TAPCELL_ROW_41_775 VGND VPWR sky130_fd_sc_hd__tapvpwrvgnd_1
XFILLER_11_482 VGND VGND VPWR VPWR sky130_fd_sc_hd__decap_3
XFILLER_7_431 VGND VGND VPWR VPWR sky130_fd_sc_hd__decap_3
XFILLER_7_475 VGND VGND VPWR VPWR sky130_fd_sc_hd__decap_3
XFILLER_112_502 VGND VGND VPWR VPWR sky130_fd_sc_hd__decap_3
X_3350_ _5129_/B _3350_/B VGND VGND VPWR VPWR _3350_/Y sky130_fd_sc_hd__nor2_2
XFILLER_97_213 VGND VGND VPWR VPWR sky130_fd_sc_hd__decap_3
XFILLER_112_568 VGND VGND VPWR VPWR sky130_fd_sc_hd__decap_3
X_5020_ _5020_/A _5020_/B _4373_/Y VGND VGND VPWR VPWR _5020_/X sky130_fd_sc_hd__or3b_2
XFILLER_24_3 VGND VGND VPWR VPWR sky130_fd_sc_hd__fill_2
Xclkbuf_leaf_2_clk clkbuf_leaf_6_clk/A VGND VGND VPWR VPWR clkload8/A sky130_fd_sc_hd__clkbuf_16
Xhold1109 _7247_/Q VGND VGND VPWR VPWR _5159_/A0 sky130_fd_sc_hd__dlygate4sd3_1
XFILLER_78_493 VGND VGND VPWR VPWR sky130_fd_sc_hd__fill_1
XFILLER_93_430 VGND VGND VPWR VPWR sky130_fd_sc_hd__fill_2
XPHY_EDGE_ROW_119_Right_119 VGND VGND VPWR VPWR sky130_fd_sc_hd__decap_3
XFILLER_38_357 VGND VGND VPWR VPWR sky130_fd_sc_hd__decap_3
XFILLER_38_379 VGND VGND VPWR VPWR sky130_fd_sc_hd__decap_3
XFILLER_53_305 VGND VGND VPWR VPWR sky130_fd_sc_hd__fill_2
XFILLER_65_143 VGND VGND VPWR VPWR sky130_fd_sc_hd__decap_3
XFILLER_66_666 VGND VGND VPWR VPWR sky130_fd_sc_hd__decap_3
XFILLER_81_614 VGND VGND VPWR VPWR sky130_fd_sc_hd__fill_2
XFILLER_93_452 VGND VGND VPWR VPWR sky130_fd_sc_hd__fill_1
XTAP_TAPCELL_ROW_49_875 VGND VPWR sky130_fd_sc_hd__tapvpwrvgnd_1
XFILLER_19_571 VGND VGND VPWR VPWR sky130_fd_sc_hd__decap_3
XFILLER_66_699 VGND VGND VPWR VPWR sky130_fd_sc_hd__fill_1
XFILLER_80_124 VGND VGND VPWR VPWR sky130_fd_sc_hd__decap_3
XFILLER_81_647 VGND VGND VPWR VPWR sky130_fd_sc_hd__decap_3
X_6971_ clkload3/A _6971_/D VGND VGND VPWR VPWR _6971_/Q sky130_fd_sc_hd__dfxtp_2
XFILLER_110_29 VGND VGND VPWR VPWR sky130_fd_sc_hd__decap_3
XFILLER_61_371 VGND VGND VPWR VPWR sky130_fd_sc_hd__decap_3
X_4804_ _4804_/A _4804_/B VGND VGND VPWR VPWR _4804_/X sky130_fd_sc_hd__or2_2
XFILLER_21_257 VGND VGND VPWR VPWR sky130_fd_sc_hd__decap_3
X_4735_ _4735_/A0 _4734_/X _4865_/S VGND VGND VPWR VPWR _7277_/D sky130_fd_sc_hd__mux2_2
XFILLER_9_81 VGND VGND VPWR VPWR sky130_fd_sc_hd__decap_3
XFILLER_119_27 VGND VGND VPWR VPWR sky130_fd_sc_hd__fill_1
XFILLER_107_318 VGND VGND VPWR VPWR sky130_fd_sc_hd__decap_3
X_4666_ _6997_/Q _5602_/B VGND VGND VPWR VPWR _4908_/A sky130_fd_sc_hd__xnor2_2
XFILLER_119_189 VGND VGND VPWR VPWR sky130_fd_sc_hd__decap_3
X_7385_ _7388_/CLK _7385_/D _6665_/Y VGND VGND VPWR VPWR _7385_/Q sky130_fd_sc_hd__dfrtp_2
Xhold910 _6893_/Q VGND VGND VPWR VPWR _6893_/D sky130_fd_sc_hd__dlygate4sd3_1
Xhold921 _6908_/Q VGND VGND VPWR VPWR _6908_/D sky130_fd_sc_hd__dlygate4sd3_1
X_6405_ _6630_/A VGND VGND VPWR VPWR _6405_/Y sky130_fd_sc_hd__inv_2
X_4597_ _4597_/A0 _5140_/A0 _4599_/S VGND VGND VPWR VPWR _7282_/D sky130_fd_sc_hd__mux2_2
X_3617_ _4614_/C _3616_/B _5103_/A1 VGND VGND VPWR VPWR _3617_/X sky130_fd_sc_hd__o21a_2
XFILLER_115_340 VGND VGND VPWR VPWR sky130_fd_sc_hd__decap_3
XFILLER_89_703 VGND VGND VPWR VPWR sky130_fd_sc_hd__decap_3
Xhold932 _6852_/Q VGND VGND VPWR VPWR _6852_/D sky130_fd_sc_hd__dlygate4sd3_1
Xhold943 _7058_/Q VGND VGND VPWR VPWR _7058_/D sky130_fd_sc_hd__dlygate4sd3_1
Xhold954 _7089_/Q VGND VGND VPWR VPWR _7089_/D sky130_fd_sc_hd__dlygate4sd3_1
X_6336_ _6463_/A VGND VGND VPWR VPWR _6336_/Y sky130_fd_sc_hd__inv_2
X_3548_ _3621_/A _4938_/A _5072_/A VGND VGND VPWR VPWR _3548_/X sky130_fd_sc_hd__or3_2
XFILLER_1_629 VGND VGND VPWR VPWR sky130_fd_sc_hd__decap_3
XFILLER_88_224 VGND VGND VPWR VPWR sky130_fd_sc_hd__decap_3
Xhold965 _7084_/Q VGND VGND VPWR VPWR _7084_/D sky130_fd_sc_hd__dlygate4sd3_1
Xhold976 _7103_/Q VGND VGND VPWR VPWR _7103_/D sky130_fd_sc_hd__dlygate4sd3_1
Xmax_cap673 _3538_/B1 VGND VGND VPWR VPWR _4289_/A sky130_fd_sc_hd__clkbuf_2
Xhold998 _7100_/Q VGND VGND VPWR VPWR _7100_/D sky130_fd_sc_hd__dlygate4sd3_1
Xhold987 _7086_/Q VGND VGND VPWR VPWR _7086_/D sky130_fd_sc_hd__dlygate4sd3_1
X_6267_ _6677_/A VGND VGND VPWR VPWR _6267_/Y sky130_fd_sc_hd__inv_2
X_3479_ _7152_/Q _3409_/X _3478_/X VGND VGND VPWR VPWR _3482_/A sky130_fd_sc_hd__a21o_2
XFILLER_57_611 VGND VGND VPWR VPWR sky130_fd_sc_hd__decap_3
XFILLER_69_460 VGND VGND VPWR VPWR sky130_fd_sc_hd__decap_3
XFILLER_88_268 VGND VGND VPWR VPWR sky130_fd_sc_hd__decap_3
XFILLER_28_35 VGND VGND VPWR VPWR sky130_fd_sc_hd__decap_3
XFILLER_29_313 VGND VGND VPWR VPWR sky130_fd_sc_hd__decap_3
XFILLER_29_346 VGND VGND VPWR VPWR sky130_fd_sc_hd__decap_3
XFILLER_56_121 VGND VGND VPWR VPWR sky130_fd_sc_hd__decap_3
XFILLER_57_644 VGND VGND VPWR VPWR sky130_fd_sc_hd__decap_3
XFILLER_69_493 VGND VGND VPWR VPWR sky130_fd_sc_hd__fill_2
XFILLER_84_430 VGND VGND VPWR VPWR sky130_fd_sc_hd__decap_3
X_5149_ _5145_/A _4852_/A _5147_/X _5148_/X VGND VGND VPWR VPWR _5149_/Y sky130_fd_sc_hd__o211ai_2
XFILLER_28_68 VGND VGND VPWR VPWR sky130_fd_sc_hd__fill_1
XFILLER_29_379 VGND VGND VPWR VPWR sky130_fd_sc_hd__decap_3
XFILLER_56_165 VGND VGND VPWR VPWR sky130_fd_sc_hd__decap_3
XFILLER_57_688 VGND VGND VPWR VPWR sky130_fd_sc_hd__decap_3
XFILLER_84_441 VGND VGND VPWR VPWR sky130_fd_sc_hd__fill_2
XFILLER_84_474 VGND VGND VPWR VPWR sky130_fd_sc_hd__fill_2
XFILLER_56_187 VGND VGND VPWR VPWR sky130_fd_sc_hd__decap_3
XFILLER_71_102 VGND VGND VPWR VPWR sky130_fd_sc_hd__decap_3
XFILLER_71_113 VGND VGND VPWR VPWR sky130_fd_sc_hd__decap_3
XFILLER_72_625 VGND VGND VPWR VPWR sky130_fd_sc_hd__decap_3
XFILLER_84_485 VGND VGND VPWR VPWR sky130_fd_sc_hd__decap_3
XFILLER_25_552 VGND VGND VPWR VPWR sky130_fd_sc_hd__decap_3
XFILLER_72_669 VGND VGND VPWR VPWR sky130_fd_sc_hd__decap_3
XFILLER_13_703 VGND VGND VPWR VPWR sky130_fd_sc_hd__decap_3
XFILLER_52_371 VGND VGND VPWR VPWR sky130_fd_sc_hd__decap_3
XFILLER_40_533 VGND VGND VPWR VPWR sky130_fd_sc_hd__decap_3
XFILLER_8_217 VGND VGND VPWR VPWR sky130_fd_sc_hd__decap_3
XFILLER_60_88 VGND VGND VPWR VPWR sky130_fd_sc_hd__decap_3
XTAP_TAPCELL_ROW_78_1235 VGND VPWR sky130_fd_sc_hd__tapvpwrvgnd_1
XFILLER_119_690 VGND VGND VPWR VPWR sky130_fd_sc_hd__decap_3
XFILLER_4_412 VGND VGND VPWR VPWR sky130_fd_sc_hd__decap_3
XFILLER_109_60 VGND VGND VPWR VPWR sky130_fd_sc_hd__decap_3
XFILLER_69_31 VGND VGND VPWR VPWR sky130_fd_sc_hd__decap_3
XFILLER_4_489 VGND VGND VPWR VPWR sky130_fd_sc_hd__decap_3
XFILLER_69_53 VGND VGND VPWR VPWR sky130_fd_sc_hd__decap_3
XFILLER_106_395 VGND VGND VPWR VPWR sky130_fd_sc_hd__decap_3
XFILLER_79_246 VGND VGND VPWR VPWR sky130_fd_sc_hd__decap_3
XFILLER_95_706 VGND VGND VPWR VPWR sky130_fd_sc_hd__decap_3
XFILLER_0_651 VGND VGND VPWR VPWR sky130_fd_sc_hd__decap_3
XFILLER_0_673 VGND VGND VPWR VPWR sky130_fd_sc_hd__decap_3
XFILLER_48_611 VGND VGND VPWR VPWR sky130_fd_sc_hd__decap_3
XFILLER_67_408 VGND VGND VPWR VPWR sky130_fd_sc_hd__decap_3
XFILLER_87_290 VGND VGND VPWR VPWR sky130_fd_sc_hd__decap_3
XFILLER_94_238 VGND VGND VPWR VPWR sky130_fd_sc_hd__decap_3
XFILLER_48_666 VGND VGND VPWR VPWR sky130_fd_sc_hd__decap_3
XFILLER_63_614 VGND VGND VPWR VPWR sky130_fd_sc_hd__fill_2
XFILLER_75_452 VGND VGND VPWR VPWR sky130_fd_sc_hd__fill_1
XFILLER_85_63 VGND VGND VPWR VPWR sky130_fd_sc_hd__decap_3
XFILLER_47_165 VGND VGND VPWR VPWR sky130_fd_sc_hd__decap_3
XFILLER_47_187 VGND VGND VPWR VPWR sky130_fd_sc_hd__decap_3
XFILLER_48_699 VGND VGND VPWR VPWR sky130_fd_sc_hd__fill_1
XFILLER_62_102 VGND VGND VPWR VPWR sky130_fd_sc_hd__decap_3
XFILLER_63_647 VGND VGND VPWR VPWR sky130_fd_sc_hd__decap_3
XFILLER_85_96 VGND VGND VPWR VPWR sky130_fd_sc_hd__decap_3
XTAP_TAPCELL_ROW_89_1375 VGND VPWR sky130_fd_sc_hd__tapvpwrvgnd_1
XTAP_TAPCELL_ROW_46_834 VGND VPWR sky130_fd_sc_hd__tapvpwrvgnd_1
XFILLER_16_530 VGND VGND VPWR VPWR sky130_fd_sc_hd__fill_2
XFILLER_90_477 VGND VGND VPWR VPWR sky130_fd_sc_hd__decap_3
XFILLER_43_382 VGND VGND VPWR VPWR sky130_fd_sc_hd__decap_3
XFILLER_71_691 VGND VGND VPWR VPWR sky130_fd_sc_hd__decap_3
XFILLER_93_6 VGND VGND VPWR VPWR sky130_fd_sc_hd__decap_3
XTAP_TAPCELL_ROW_26_580 VGND VPWR sky130_fd_sc_hd__tapvpwrvgnd_1
XFILLER_31_577 VGND VGND VPWR VPWR sky130_fd_sc_hd__decap_3
X_4520_ _4520_/A0 _7287_/Q _4532_/S VGND VGND VPWR VPWR _7319_/D sky130_fd_sc_hd__mux2_2
XFILLER_117_638 VGND VGND VPWR VPWR sky130_fd_sc_hd__decap_3
XFILLER_7_272 VGND VGND VPWR VPWR sky130_fd_sc_hd__fill_1
X_4451_ _4451_/A _4451_/B VGND VGND VPWR VPWR _4765_/B sky130_fd_sc_hd__nor2_2
XFILLER_116_159 VGND VGND VPWR VPWR sky130_fd_sc_hd__decap_3
X_7170_ _7362_/CLK _7170_/D _6450_/Y VGND VGND VPWR VPWR _7170_/Q sky130_fd_sc_hd__dfrtp_2
X_3402_ _3385_/Y _3401_/X _3318_/B VGND VGND VPWR VPWR _3421_/C sky130_fd_sc_hd__a21oi_4
XFILLER_98_511 VGND VGND VPWR VPWR sky130_fd_sc_hd__decap_3
XFILLER_98_533 VGND VGND VPWR VPWR sky130_fd_sc_hd__decap_3
X_4382_ _4950_/A _4967_/B VGND VGND VPWR VPWR _4383_/C sky130_fd_sc_hd__nor2_2
XFILLER_98_566 VGND VGND VPWR VPWR sky130_fd_sc_hd__decap_3
XFILLER_100_516 VGND VGND VPWR VPWR sky130_fd_sc_hd__decap_3
XFILLER_112_365 VGND VGND VPWR VPWR sky130_fd_sc_hd__decap_3
XFILLER_58_408 VGND VGND VPWR VPWR sky130_fd_sc_hd__decap_3
XFILLER_85_216 VGND VGND VPWR VPWR sky130_fd_sc_hd__decap_3
XPHY_EDGE_ROW_7_Right_7 VGND VGND VPWR VPWR sky130_fd_sc_hd__decap_3
XFILLER_38_110 VGND VGND VPWR VPWR sky130_fd_sc_hd__decap_3
XFILLER_39_644 VGND VGND VPWR VPWR sky130_fd_sc_hd__decap_3
XFILLER_85_249 VGND VGND VPWR VPWR sky130_fd_sc_hd__decap_3
X_5003_ _5003_/A _5003_/B VGND VGND VPWR VPWR _5003_/X sky130_fd_sc_hd__or2_2
XFILLER_26_305 VGND VGND VPWR VPWR sky130_fd_sc_hd__decap_3
XFILLER_26_338 VGND VGND VPWR VPWR sky130_fd_sc_hd__decap_3
XFILLER_38_176 VGND VGND VPWR VPWR sky130_fd_sc_hd__decap_3
XFILLER_39_688 VGND VGND VPWR VPWR sky130_fd_sc_hd__decap_3
XFILLER_53_113 VGND VGND VPWR VPWR sky130_fd_sc_hd__decap_3
XFILLER_54_636 VGND VGND VPWR VPWR sky130_fd_sc_hd__decap_3
XFILLER_66_474 VGND VGND VPWR VPWR sky130_fd_sc_hd__fill_2
XFILLER_54_669 VGND VGND VPWR VPWR sky130_fd_sc_hd__decap_3
XFILLER_81_455 VGND VGND VPWR VPWR sky130_fd_sc_hd__fill_1
XFILLER_93_293 VGND VGND VPWR VPWR sky130_fd_sc_hd__decap_3
X_6954_ _6968_/CLK _6954_/D VGND VGND VPWR VPWR _6954_/Q sky130_fd_sc_hd__dfxtp_2
XFILLER_34_360 VGND VGND VPWR VPWR sky130_fd_sc_hd__decap_3
XFILLER_22_533 VGND VGND VPWR VPWR sky130_fd_sc_hd__fill_1
X_6885_ _6941_/CLK _6885_/D VGND VGND VPWR VPWR _6885_/Q sky130_fd_sc_hd__dfxtp_2
XTAP_TAPCELL_ROW_62_1036 VGND VPWR sky130_fd_sc_hd__tapvpwrvgnd_1
XFILLER_108_616 VGND VGND VPWR VPWR sky130_fd_sc_hd__decap_3
X_4718_ _4718_/A0 _4716_/X _4865_/S VGND VGND VPWR VPWR _7278_/D sky130_fd_sc_hd__mux2_4
XFILLER_107_137 VGND VGND VPWR VPWR sky130_fd_sc_hd__decap_3
XFILLER_30_25 VGND VGND VPWR VPWR sky130_fd_sc_hd__decap_3
X_4649_ _4649_/A _4649_/B _4425_/C VGND VGND VPWR VPWR _4652_/A sky130_fd_sc_hd__nor3b_2
XFILLER_116_660 VGND VGND VPWR VPWR sky130_fd_sc_hd__decap_3
XFILLER_116_693 VGND VGND VPWR VPWR sky130_fd_sc_hd__decap_3
XFILLER_89_511 VGND VGND VPWR VPWR sky130_fd_sc_hd__fill_1
X_7368_ _7370_/CLK _7368_/D _6648_/Y VGND VGND VPWR VPWR _7368_/Q sky130_fd_sc_hd__dfrtp_2
Xhold740 _6967_/Q VGND VGND VPWR VPWR _6967_/D sky130_fd_sc_hd__dlygate4sd3_1
Xhold751 _6789_/Q VGND VGND VPWR VPWR _6789_/D sky130_fd_sc_hd__dlygate4sd3_1
Xhold762 _6823_/Q VGND VGND VPWR VPWR _6823_/D sky130_fd_sc_hd__dlygate4sd3_1
Xhold773 _6946_/Q VGND VGND VPWR VPWR _6946_/D sky130_fd_sc_hd__dlygate4sd3_1
XFILLER_103_321 VGND VGND VPWR VPWR sky130_fd_sc_hd__decap_3
XFILLER_77_706 VGND VGND VPWR VPWR sky130_fd_sc_hd__decap_3
X_7299_ _7342_/CLK _7299_/D _6579_/Y VGND VGND VPWR VPWR _7299_/Q sky130_fd_sc_hd__dfrtp_2
Xhold784 _6832_/Q VGND VGND VPWR VPWR _6832_/D sky130_fd_sc_hd__dlygate4sd3_1
Xhold795 _6821_/Q VGND VGND VPWR VPWR _6821_/D sky130_fd_sc_hd__dlygate4sd3_1
X_6319_ _6671_/A VGND VGND VPWR VPWR _6319_/Y sky130_fd_sc_hd__inv_2
XTAP_TAPCELL_ROW_73_1165 VGND VPWR sky130_fd_sc_hd__tapvpwrvgnd_1
XFILLER_103_354 VGND VGND VPWR VPWR sky130_fd_sc_hd__fill_1
XFILLER_103_365 VGND VGND VPWR VPWR sky130_fd_sc_hd__decap_3
XFILLER_39_34 VGND VGND VPWR VPWR sky130_fd_sc_hd__decap_3
XFILLER_76_216 VGND VGND VPWR VPWR sky130_fd_sc_hd__decap_3
XTAP_TAPCELL_ROW_73_1176 VGND VPWR sky130_fd_sc_hd__tapvpwrvgnd_1
XFILLER_76_249 VGND VGND VPWR VPWR sky130_fd_sc_hd__decap_3
XFILLER_55_11 VGND VGND VPWR VPWR sky130_fd_sc_hd__decap_3
XFILLER_57_441 VGND VGND VPWR VPWR sky130_fd_sc_hd__decap_3
XFILLER_69_290 VGND VGND VPWR VPWR sky130_fd_sc_hd__decap_3
XFILLER_91_208 VGND VGND VPWR VPWR sky130_fd_sc_hd__fill_2
XFILLER_29_165 VGND VGND VPWR VPWR sky130_fd_sc_hd__decap_3
XFILLER_29_187 VGND VGND VPWR VPWR sky130_fd_sc_hd__decap_3
XFILLER_45_614 VGND VGND VPWR VPWR sky130_fd_sc_hd__fill_2
XFILLER_72_400 VGND VGND VPWR VPWR sky130_fd_sc_hd__decap_3
XFILLER_17_349 VGND VGND VPWR VPWR sky130_fd_sc_hd__fill_1
XFILLER_45_647 VGND VGND VPWR VPWR sky130_fd_sc_hd__decap_3
XFILLER_55_55 VGND VGND VPWR VPWR sky130_fd_sc_hd__fill_1
XFILLER_72_444 VGND VGND VPWR VPWR sky130_fd_sc_hd__decap_3
XFILLER_84_293 VGND VGND VPWR VPWR sky130_fd_sc_hd__decap_3
XFILLER_25_360 VGND VGND VPWR VPWR sky130_fd_sc_hd__decap_3
XFILLER_60_628 VGND VGND VPWR VPWR sky130_fd_sc_hd__decap_3
XFILLER_72_477 VGND VGND VPWR VPWR sky130_fd_sc_hd__fill_1
XFILLER_111_72 VGND VGND VPWR VPWR sky130_fd_sc_hd__decap_3
XFILLER_13_522 VGND VGND VPWR VPWR sky130_fd_sc_hd__decap_3
XFILLER_53_691 VGND VGND VPWR VPWR sky130_fd_sc_hd__decap_3
XTAP_TAPCELL_ROW_23_550 VGND VPWR sky130_fd_sc_hd__tapvpwrvgnd_1
XFILLER_13_588 VGND VGND VPWR VPWR sky130_fd_sc_hd__decap_3
XTAP_TAPCELL_ROW_51_892 VGND VPWR sky130_fd_sc_hd__tapvpwrvgnd_1
XFILLER_9_548 VGND VGND VPWR VPWR sky130_fd_sc_hd__decap_3
XFILLER_114_619 VGND VGND VPWR VPWR sky130_fd_sc_hd__decap_3
XFILLER_99_308 VGND VGND VPWR VPWR sky130_fd_sc_hd__decap_3
XFILLER_107_671 VGND VGND VPWR VPWR sky130_fd_sc_hd__fill_1
XFILLER_107_682 VGND VGND VPWR VPWR sky130_fd_sc_hd__decap_3
XFILLER_4_297 VGND VGND VPWR VPWR sky130_fd_sc_hd__decap_3
XFILLER_95_514 VGND VGND VPWR VPWR sky130_fd_sc_hd__decap_3
XFILLER_67_216 VGND VGND VPWR VPWR sky130_fd_sc_hd__decap_3
XFILLER_95_547 VGND VGND VPWR VPWR sky130_fd_sc_hd__decap_3
XFILLER_83_709 VGND VGND VPWR VPWR sky130_fd_sc_hd__decap_3
XFILLER_95_569 VGND VGND VPWR VPWR sky130_fd_sc_hd__fill_1
XFILLER_36_625 VGND VGND VPWR VPWR sky130_fd_sc_hd__decap_3
XFILLER_63_422 VGND VGND VPWR VPWR sky130_fd_sc_hd__decap_3
XFILLER_75_271 VGND VGND VPWR VPWR sky130_fd_sc_hd__decap_3
XFILLER_82_219 VGND VGND VPWR VPWR sky130_fd_sc_hd__decap_3
XTAP_TAPCELL_ROW_59_992 VGND VPWR sky130_fd_sc_hd__tapvpwrvgnd_1
XFILLER_36_669 VGND VGND VPWR VPWR sky130_fd_sc_hd__decap_3
XFILLER_63_444 VGND VGND VPWR VPWR sky130_fd_sc_hd__decap_3
XFILLER_90_230 VGND VGND VPWR VPWR sky130_fd_sc_hd__decap_3
Xplace422 _4248_/A VGND VGND VPWR VPWR _4429_/C1 sky130_fd_sc_hd__buf_2
Xplace411 _4335_/A2 VGND VGND VPWR VPWR _5142_/S sky130_fd_sc_hd__buf_2
Xplace400 _3618_/C VGND VGND VPWR VPWR _4764_/B sky130_fd_sc_hd__buf_2
XFILLER_35_157 VGND VGND VPWR VPWR sky130_fd_sc_hd__decap_3
XFILLER_51_617 VGND VGND VPWR VPWR sky130_fd_sc_hd__decap_3
XFILLER_90_274 VGND VGND VPWR VPWR sky130_fd_sc_hd__decap_3
Xplace455 _4532_/S VGND VGND VPWR VPWR _4233_/B1 sky130_fd_sc_hd__buf_2
Xplace444 _4606_/A VGND VGND VPWR VPWR _5666_/A sky130_fd_sc_hd__buf_2
Xplace433 _3442_/A VGND VGND VPWR VPWR _5104_/A sky130_fd_sc_hd__buf_2
Xplace488 _3344_/Y VGND VGND VPWR VPWR _4677_/B sky130_fd_sc_hd__buf_2
Xplace477 _3952_/S VGND VGND VPWR VPWR _3954_/S sky130_fd_sc_hd__buf_2
Xplace466 _4181_/B1 VGND VGND VPWR VPWR _4419_/B1 sky130_fd_sc_hd__buf_2
XFILLER_43_190 VGND VGND VPWR VPWR sky130_fd_sc_hd__decap_3
Xplace499 _3318_/B VGND VGND VPWR VPWR _4353_/A2 sky130_fd_sc_hd__buf_2
X_6670_ _6671_/A VGND VGND VPWR VPWR _6670_/Y sky130_fd_sc_hd__inv_2
X_3882_ _6974_/Q _3910_/B1 _5660_/B _6969_/Q _3881_/X VGND VGND VPWR VPWR _3882_/X
+ sky130_fd_sc_hd__a221o_2
XFILLER_31_363 VGND VGND VPWR VPWR sky130_fd_sc_hd__decap_3
X_5621_ _5621_/A VGND VGND VPWR VPWR _5622_/A sky130_fd_sc_hd__inv_2
XFILLER_8_581 VGND VGND VPWR VPWR sky130_fd_sc_hd__decap_3
XFILLER_8_592 VGND VGND VPWR VPWR sky130_fd_sc_hd__decap_3
X_4503_ _4503_/A0 _7296_/Q _4517_/S VGND VGND VPWR VPWR _4503_/X sky130_fd_sc_hd__mux2_2
XFILLER_6_93 VGND VGND VPWR VPWR sky130_fd_sc_hd__decap_3
X_7222_ _7313_/CLK _7222_/D _6502_/Y VGND VGND VPWR VPWR _7222_/Q sky130_fd_sc_hd__dfrtp_2
X_4434_ _7111_/Q _4434_/A2 _4434_/B1 _7143_/Q _4433_/X VGND VGND VPWR VPWR _4434_/X
+ sky130_fd_sc_hd__a221o_2
XFILLER_113_641 VGND VGND VPWR VPWR sky130_fd_sc_hd__decap_3
X_7153_ _7313_/CLK _7153_/D _6433_/Y VGND VGND VPWR VPWR _7153_/Q sky130_fd_sc_hd__dfrtp_2
X_4365_ _4365_/A _4365_/B _4365_/C VGND VGND VPWR VPWR _4365_/X sky130_fd_sc_hd__and3_2
XFILLER_113_685 VGND VGND VPWR VPWR sky130_fd_sc_hd__decap_3
XFILLER_59_706 VGND VGND VPWR VPWR sky130_fd_sc_hd__decap_3
X_7084_ _7086_/CLK _7084_/D _6364_/Y VGND VGND VPWR VPWR _7084_/Q sky130_fd_sc_hd__dfrtp_2
X_3316_ _3365_/A _6983_/Q VGND VGND VPWR VPWR _3332_/B sky130_fd_sc_hd__nor2b_2
XFILLER_112_195 VGND VGND VPWR VPWR sky130_fd_sc_hd__fill_1
XFILLER_58_227 VGND VGND VPWR VPWR sky130_fd_sc_hd__decap_3
XFILLER_86_536 VGND VGND VPWR VPWR sky130_fd_sc_hd__decap_3
XFILLER_98_385 VGND VGND VPWR VPWR sky130_fd_sc_hd__decap_3
X_4296_ _4292_/A wire671/X _4295_/X VGND VGND VPWR VPWR _4297_/B sky130_fd_sc_hd__a21oi_2
XFILLER_27_603 VGND VGND VPWR VPWR sky130_fd_sc_hd__decap_3
XFILLER_54_411 VGND VGND VPWR VPWR sky130_fd_sc_hd__decap_3
XFILLER_66_260 VGND VGND VPWR VPWR sky130_fd_sc_hd__decap_3
XFILLER_94_580 VGND VGND VPWR VPWR sky130_fd_sc_hd__fill_2
XFILLER_26_135 VGND VGND VPWR VPWR sky130_fd_sc_hd__fill_1
XFILLER_27_647 VGND VGND VPWR VPWR sky130_fd_sc_hd__decap_3
XFILLER_54_433 VGND VGND VPWR VPWR sky130_fd_sc_hd__fill_2
XTAP_TAPCELL_ROW_1_267 VGND VPWR sky130_fd_sc_hd__tapvpwrvgnd_1
XFILLER_42_606 VGND VGND VPWR VPWR sky130_fd_sc_hd__decap_3
XFILLER_35_691 VGND VGND VPWR VPWR sky130_fd_sc_hd__decap_3
XFILLER_41_116 VGND VGND VPWR VPWR sky130_fd_sc_hd__fill_1
XFILLER_42_639 VGND VGND VPWR VPWR sky130_fd_sc_hd__decap_3
X_6937_ _6943_/CLK _6937_/D VGND VGND VPWR VPWR _6937_/Q sky130_fd_sc_hd__dfxtp_2
XFILLER_22_352 VGND VGND VPWR VPWR sky130_fd_sc_hd__decap_3
X_6868_ clkload8/A _6868_/D VGND VGND VPWR VPWR _6868_/Q sky130_fd_sc_hd__dfxtp_2
XFILLER_22_374 VGND VGND VPWR VPWR sky130_fd_sc_hd__fill_1
XFILLER_50_672 VGND VGND VPWR VPWR sky130_fd_sc_hd__decap_3
XFILLER_10_569 VGND VGND VPWR VPWR sky130_fd_sc_hd__decap_3
XFILLER_41_57 VGND VGND VPWR VPWR sky130_fd_sc_hd__decap_3
X_6799_ _6943_/CLK _6799_/D VGND VGND VPWR VPWR _6799_/Q sky130_fd_sc_hd__dfxtp_2
XFILLER_108_413 VGND VGND VPWR VPWR sky130_fd_sc_hd__decap_3
XFILLER_108_424 VGND VGND VPWR VPWR sky130_fd_sc_hd__fill_2
XFILLER_41_68 VGND VGND VPWR VPWR sky130_fd_sc_hd__fill_2
XFILLER_108_457 VGND VGND VPWR VPWR sky130_fd_sc_hd__decap_3
XFILLER_2_713 VGND VGND VPWR VPWR sky130_fd_sc_hd__fill_1
XFILLER_116_490 VGND VGND VPWR VPWR sky130_fd_sc_hd__fill_2
XFILLER_1_223 VGND VGND VPWR VPWR sky130_fd_sc_hd__fill_1
XTAP_TAPCELL_ROW_9_367 VGND VPWR sky130_fd_sc_hd__tapvpwrvgnd_1
XFILLER_103_140 VGND VGND VPWR VPWR sky130_fd_sc_hd__decap_3
XFILLER_104_663 VGND VGND VPWR VPWR sky130_fd_sc_hd__decap_3
XFILLER_1_245 VGND VGND VPWR VPWR sky130_fd_sc_hd__fill_2
XFILLER_104_696 VGND VGND VPWR VPWR sky130_fd_sc_hd__decap_3
XFILLER_49_216 VGND VGND VPWR VPWR sky130_fd_sc_hd__decap_3
XFILLER_89_396 VGND VGND VPWR VPWR sky130_fd_sc_hd__fill_2
XFILLER_103_195 VGND VGND VPWR VPWR sky130_fd_sc_hd__decap_3
XFILLER_106_83 VGND VGND VPWR VPWR sky130_fd_sc_hd__fill_1
XFILLER_65_709 VGND VGND VPWR VPWR sky130_fd_sc_hd__decap_3
XFILLER_66_32 VGND VGND VPWR VPWR sky130_fd_sc_hd__decap_3
XFILLER_18_625 VGND VGND VPWR VPWR sky130_fd_sc_hd__decap_3
XFILLER_45_400 VGND VGND VPWR VPWR sky130_fd_sc_hd__decap_3
XFILLER_64_219 VGND VGND VPWR VPWR sky130_fd_sc_hd__decap_3
Xhold1270 _7025_/Q VGND VGND VPWR VPWR _5605_/A sky130_fd_sc_hd__dlygate4sd3_1
XFILLER_18_669 VGND VGND VPWR VPWR sky130_fd_sc_hd__decap_3
Xhold1281 _7179_/Q VGND VGND VPWR VPWR _5302_/A0 sky130_fd_sc_hd__dlygate4sd3_1
Xhold1292 _7310_/Q VGND VGND VPWR VPWR _4540_/A sky130_fd_sc_hd__dlygate4sd3_1
XTAP_TAPCELL_ROW_86_1334 VGND VPWR sky130_fd_sc_hd__tapvpwrvgnd_1
XFILLER_33_606 VGND VGND VPWR VPWR sky130_fd_sc_hd__decap_3
XFILLER_33_617 VGND VGND VPWR VPWR sky130_fd_sc_hd__decap_3
XFILLER_72_241 VGND VGND VPWR VPWR sky130_fd_sc_hd__decap_3
XTAP_TAPCELL_ROW_56_962 VGND VPWR sky130_fd_sc_hd__tapvpwrvgnd_1
XFILLER_60_447 VGND VGND VPWR VPWR sky130_fd_sc_hd__decap_3
XFILLER_72_285 VGND VGND VPWR VPWR sky130_fd_sc_hd__decap_3
XFILLER_72_296 VGND VGND VPWR VPWR sky130_fd_sc_hd__decap_3
XFILLER_82_64 VGND VGND VPWR VPWR sky130_fd_sc_hd__decap_3
XFILLER_41_650 VGND VGND VPWR VPWR sky130_fd_sc_hd__decap_3
XFILLER_82_97 VGND VGND VPWR VPWR sky130_fd_sc_hd__decap_3
XFILLER_41_694 VGND VGND VPWR VPWR sky130_fd_sc_hd__decap_3
XFILLER_9_323 VGND VGND VPWR VPWR sky130_fd_sc_hd__decap_3
XFILLER_13_396 VGND VGND VPWR VPWR sky130_fd_sc_hd__decap_3
XFILLER_40_193 VGND VGND VPWR VPWR sky130_fd_sc_hd__decap_3
XFILLER_9_389 VGND VGND VPWR VPWR sky130_fd_sc_hd__decap_3
XTAP_TAPCELL_ROW_97_1474 VGND VPWR sky130_fd_sc_hd__tapvpwrvgnd_1
XFILLER_56_6 VGND VGND VPWR VPWR sky130_fd_sc_hd__fill_2
XFILLER_5_551 VGND VGND VPWR VPWR sky130_fd_sc_hd__decap_3
XFILLER_5_573 VGND VGND VPWR VPWR sky130_fd_sc_hd__decap_3
XFILLER_99_116 VGND VGND VPWR VPWR sky130_fd_sc_hd__decap_3
XFILLER_114_449 VGND VGND VPWR VPWR sky130_fd_sc_hd__decap_3
XFILLER_68_514 VGND VGND VPWR VPWR sky130_fd_sc_hd__fill_1
X_4150_ _7234_/Q _4353_/A2 _4272_/B _7362_/Q VGND VGND VPWR VPWR _4150_/X sky130_fd_sc_hd__a22o_2
XFILLER_110_622 VGND VGND VPWR VPWR sky130_fd_sc_hd__decap_3
XFILLER_95_311 VGND VGND VPWR VPWR sky130_fd_sc_hd__decap_3
XFILLER_110_666 VGND VGND VPWR VPWR sky130_fd_sc_hd__decap_3
X_4081_ _4451_/A _4451_/B VGND VGND VPWR VPWR _4081_/X sky130_fd_sc_hd__or2b_2
XFILLER_110_699 VGND VGND VPWR VPWR sky130_fd_sc_hd__fill_1
XFILLER_48_271 VGND VGND VPWR VPWR sky130_fd_sc_hd__decap_3
XFILLER_83_517 VGND VGND VPWR VPWR sky130_fd_sc_hd__decap_3
XFILLER_95_377 VGND VGND VPWR VPWR sky130_fd_sc_hd__decap_3
XFILLER_24_628 VGND VGND VPWR VPWR sky130_fd_sc_hd__decap_3
XFILLER_36_466 VGND VGND VPWR VPWR sky130_fd_sc_hd__decap_3
XFILLER_36_477 VGND VGND VPWR VPWR sky130_fd_sc_hd__fill_1
XFILLER_91_561 VGND VGND VPWR VPWR sky130_fd_sc_hd__decap_3
XFILLER_17_691 VGND VGND VPWR VPWR sky130_fd_sc_hd__decap_3
XFILLER_36_499 VGND VGND VPWR VPWR sky130_fd_sc_hd__decap_3
XFILLER_63_274 VGND VGND VPWR VPWR sky130_fd_sc_hd__fill_1
XFILLER_91_583 VGND VGND VPWR VPWR sky130_fd_sc_hd__decap_3
X_4983_ _5579_/S _4983_/B _4983_/C VGND VGND VPWR VPWR _4983_/X sky130_fd_sc_hd__and3_2
XTAP_TAPCELL_ROW_106_1581 VGND VPWR sky130_fd_sc_hd__tapvpwrvgnd_1
X_6722_ clkload4/A _6722_/D VGND VGND VPWR VPWR _6722_/Q sky130_fd_sc_hd__dfxtp_2
XFILLER_32_672 VGND VGND VPWR VPWR sky130_fd_sc_hd__decap_3
X_6653_ _6653_/A VGND VGND VPWR VPWR _6653_/Y sky130_fd_sc_hd__inv_2
XTAP_TAPCELL_ROW_34_689 VGND VPWR sky130_fd_sc_hd__tapvpwrvgnd_1
XTAP_TAPCELL_ROW_34_678 VGND VPWR sky130_fd_sc_hd__tapvpwrvgnd_1
XFILLER_31_193 VGND VGND VPWR VPWR sky130_fd_sc_hd__decap_3
XFILLER_117_210 VGND VGND VPWR VPWR sky130_fd_sc_hd__decap_3
X_6584_ _6584_/A VGND VGND VPWR VPWR _6584_/Y sky130_fd_sc_hd__inv_2
X_3796_ _6726_/Q _3892_/A2 _3913_/A2 _6976_/Q _3795_/X VGND VGND VPWR VPWR _3796_/X
+ sky130_fd_sc_hd__a221o_2
XFILLER_117_221 VGND VGND VPWR VPWR sky130_fd_sc_hd__decap_3
XFILLER_117_276 VGND VGND VPWR VPWR sky130_fd_sc_hd__fill_1
Xoutput620 _5648_/A VGND VGND VPWR VPWR instruction_out[27] sky130_fd_sc_hd__clkdlybuf4s25_1
XFILLER_105_449 VGND VGND VPWR VPWR sky130_fd_sc_hd__decap_3
X_7205_ _7400_/CLK _7205_/D _6485_/Y VGND VGND VPWR VPWR _7205_/Q sky130_fd_sc_hd__dfrtp_2
Xoutput653 _5667_/A VGND VGND VPWR VPWR pc_out[2] sky130_fd_sc_hd__clkdlybuf4s25_1
Xoutput642 _7010_/Q VGND VGND VPWR VPWR pc_out[1] sky130_fd_sc_hd__clkdlybuf4s25_1
Xoutput631 _7009_/Q VGND VGND VPWR VPWR pc_out[0] sky130_fd_sc_hd__clkdlybuf4s25_1
X_4417_ _7304_/Q _4914_/S _4417_/B1 _7112_/Q _4416_/X VGND VGND VPWR VPWR _4417_/X
+ sky130_fd_sc_hd__a221o_2
XFILLER_99_650 VGND VGND VPWR VPWR sky130_fd_sc_hd__decap_3
XFILLER_59_514 VGND VGND VPWR VPWR sky130_fd_sc_hd__decap_3
XFILLER_86_300 VGND VGND VPWR VPWR sky130_fd_sc_hd__decap_3
XFILLER_98_182 VGND VGND VPWR VPWR sky130_fd_sc_hd__decap_3
X_7136_ _7362_/CLK _7136_/D _6416_/Y VGND VGND VPWR VPWR _7136_/Q sky130_fd_sc_hd__dfrtp_2
X_4348_ _7161_/Q _3366_/X _4348_/B1 _7129_/Q _4347_/X VGND VGND VPWR VPWR _4348_/X
+ sky130_fd_sc_hd__a221o_2
XTAP_TAPCELL_ROW_70_1135 VGND VPWR sky130_fd_sc_hd__tapvpwrvgnd_1
XTAP_TAPCELL_ROW_6_337 VGND VPWR sky130_fd_sc_hd__tapvpwrvgnd_1
XFILLER_99_694 VGND VGND VPWR VPWR sky130_fd_sc_hd__decap_3
XFILLER_101_644 VGND VGND VPWR VPWR sky130_fd_sc_hd__decap_3
XFILLER_47_709 VGND VGND VPWR VPWR sky130_fd_sc_hd__decap_3
X_7067_ _7387_/CLK _7067_/D _6347_/Y VGND VGND VPWR VPWR _7067_/Q sky130_fd_sc_hd__dfrtp_2
X_4279_ _7318_/Q _3987_/S _4348_/B1 _7126_/Q VGND VGND VPWR VPWR _4279_/X sky130_fd_sc_hd__a22o_2
XFILLER_100_165 VGND VGND VPWR VPWR sky130_fd_sc_hd__decap_3
XFILLER_101_688 VGND VGND VPWR VPWR sky130_fd_sc_hd__decap_3
XFILLER_74_528 VGND VGND VPWR VPWR sky130_fd_sc_hd__decap_3
XFILLER_100_187 VGND VGND VPWR VPWR sky130_fd_sc_hd__decap_3
XFILLER_27_444 VGND VGND VPWR VPWR sky130_fd_sc_hd__decap_3
XFILLER_36_24 VGND VGND VPWR VPWR sky130_fd_sc_hd__decap_3
XFILLER_39_293 VGND VGND VPWR VPWR sky130_fd_sc_hd__decap_3
XFILLER_15_617 VGND VGND VPWR VPWR sky130_fd_sc_hd__decap_3
XFILLER_36_57 VGND VGND VPWR VPWR sky130_fd_sc_hd__fill_2
XFILLER_54_241 VGND VGND VPWR VPWR sky130_fd_sc_hd__decap_3
XFILLER_70_701 VGND VGND VPWR VPWR sky130_fd_sc_hd__decap_3
XFILLER_54_274 VGND VGND VPWR VPWR sky130_fd_sc_hd__decap_3
XTAP_TAPCELL_ROW_53_921 VGND VPWR sky130_fd_sc_hd__tapvpwrvgnd_1
XFILLER_23_650 VGND VGND VPWR VPWR sky130_fd_sc_hd__decap_3
XFILLER_42_447 VGND VGND VPWR VPWR sky130_fd_sc_hd__decap_3
XFILLER_42_469 VGND VGND VPWR VPWR sky130_fd_sc_hd__decap_3
XFILLER_23_694 VGND VGND VPWR VPWR sky130_fd_sc_hd__decap_3
XFILLER_52_45 VGND VGND VPWR VPWR sky130_fd_sc_hd__decap_3
XTAP_TAPCELL_ROW_81_1275 VGND VPWR sky130_fd_sc_hd__tapvpwrvgnd_1
XFILLER_109_700 VGND VGND VPWR VPWR sky130_fd_sc_hd__decap_3
XFILLER_50_480 VGND VGND VPWR VPWR sky130_fd_sc_hd__fill_2
XFILLER_52_67 VGND VGND VPWR VPWR sky130_fd_sc_hd__decap_3
XFILLER_10_377 VGND VGND VPWR VPWR sky130_fd_sc_hd__decap_3
XFILLER_6_315 VGND VGND VPWR VPWR sky130_fd_sc_hd__decap_3
XFILLER_10_399 VGND VGND VPWR VPWR sky130_fd_sc_hd__decap_3
XFILLER_108_265 VGND VGND VPWR VPWR sky130_fd_sc_hd__decap_3
XFILLER_2_510 VGND VGND VPWR VPWR sky130_fd_sc_hd__decap_3
XFILLER_117_60 VGND VGND VPWR VPWR sky130_fd_sc_hd__decap_3
XFILLER_2_554 VGND VGND VPWR VPWR sky130_fd_sc_hd__decap_3
XFILLER_104_471 VGND VGND VPWR VPWR sky130_fd_sc_hd__decap_3
XFILLER_117_93 VGND VGND VPWR VPWR sky130_fd_sc_hd__decap_3
XFILLER_2_587 VGND VGND VPWR VPWR sky130_fd_sc_hd__fill_1
XFILLER_2_598 VGND VGND VPWR VPWR sky130_fd_sc_hd__decap_3
XFILLER_77_322 VGND VGND VPWR VPWR sky130_fd_sc_hd__decap_3
XFILLER_96_119 VGND VGND VPWR VPWR sky130_fd_sc_hd__decap_3
XFILLER_77_355 VGND VGND VPWR VPWR sky130_fd_sc_hd__decap_3
XFILLER_77_97 VGND VGND VPWR VPWR sky130_fd_sc_hd__decap_3
XFILLER_89_193 VGND VGND VPWR VPWR sky130_fd_sc_hd__decap_3
XFILLER_65_517 VGND VGND VPWR VPWR sky130_fd_sc_hd__decap_3
XFILLER_77_399 VGND VGND VPWR VPWR sky130_fd_sc_hd__decap_3
XFILLER_18_433 VGND VGND VPWR VPWR sky130_fd_sc_hd__fill_1
XFILLER_18_477 VGND VGND VPWR VPWR sky130_fd_sc_hd__decap_3
XFILLER_61_712 VGND VGND VPWR VPWR sky130_fd_sc_hd__fill_2
XFILLER_60_200 VGND VGND VPWR VPWR sky130_fd_sc_hd__decap_3
XFILLER_93_96 VGND VGND VPWR VPWR sky130_fd_sc_hd__decap_3
XFILLER_21_609 VGND VGND VPWR VPWR sky130_fd_sc_hd__decap_3
XFILLER_33_447 VGND VGND VPWR VPWR sky130_fd_sc_hd__fill_1
XFILLER_33_458 VGND VGND VPWR VPWR sky130_fd_sc_hd__decap_3
XFILLER_60_233 VGND VGND VPWR VPWR sky130_fd_sc_hd__fill_1
XFILLER_14_672 VGND VGND VPWR VPWR sky130_fd_sc_hd__decap_3
XFILLER_60_266 VGND VGND VPWR VPWR sky130_fd_sc_hd__decap_3
XTAP_TAPCELL_ROW_31_648 VGND VPWR sky130_fd_sc_hd__tapvpwrvgnd_1
X_3650_ _3991_/B VGND VGND VPWR VPWR _3665_/A sky130_fd_sc_hd__inv_2
XFILLER_9_175 VGND VGND VPWR VPWR sky130_fd_sc_hd__fill_2
X_3581_ _7156_/Q _3409_/X _3579_/X _3580_/X VGND VGND VPWR VPWR _3583_/B sky130_fd_sc_hd__a211o_2
XFILLER_115_703 VGND VGND VPWR VPWR sky130_fd_sc_hd__decap_3
XFILLER_54_3 VGND VGND VPWR VPWR sky130_fd_sc_hd__decap_3
XTAP_TAPCELL_ROW_11_394 VGND VPWR sky130_fd_sc_hd__tapvpwrvgnd_1
XFILLER_114_235 VGND VGND VPWR VPWR sky130_fd_sc_hd__decap_3
XFILLER_5_370 VGND VGND VPWR VPWR sky130_fd_sc_hd__decap_3
X_5251_ _5251_/A0 _4899_/X _5274_/S VGND VGND VPWR VPWR _7204_/D sky130_fd_sc_hd__mux2_2
X_4202_ _4202_/A VGND VGND VPWR VPWR _4203_/C sky130_fd_sc_hd__inv_2
XFILLER_68_300 VGND VGND VPWR VPWR sky130_fd_sc_hd__decap_3
XFILLER_68_322 VGND VGND VPWR VPWR sky130_fd_sc_hd__fill_1
XFILLER_87_119 VGND VGND VPWR VPWR sky130_fd_sc_hd__decap_3
XFILLER_96_631 VGND VGND VPWR VPWR sky130_fd_sc_hd__decap_3
X_5182_ _7237_/Q _5207_/B VGND VGND VPWR VPWR _7237_/D sky130_fd_sc_hd__and2_2
XFILLER_29_709 VGND VGND VPWR VPWR sky130_fd_sc_hd__decap_3
XFILLER_3_61 VGND VGND VPWR VPWR sky130_fd_sc_hd__decap_3
XFILLER_3_72 VGND VGND VPWR VPWR sky130_fd_sc_hd__decap_3
X_4133_ _7363_/Q _4394_/B _4436_/B1 _7171_/Q VGND VGND VPWR VPWR _4133_/X sky130_fd_sc_hd__a22o_2
XFILLER_110_463 VGND VGND VPWR VPWR sky130_fd_sc_hd__decap_3
XFILLER_113_18 VGND VGND VPWR VPWR sky130_fd_sc_hd__fill_2
XFILLER_56_506 VGND VGND VPWR VPWR sky130_fd_sc_hd__decap_3
XFILLER_95_152 VGND VGND VPWR VPWR sky130_fd_sc_hd__decap_3
XFILLER_96_675 VGND VGND VPWR VPWR sky130_fd_sc_hd__decap_3
X_4064_ _7372_/Q _4416_/A2 _4914_/S _7308_/Q _4063_/X VGND VGND VPWR VPWR _4064_/X
+ sky130_fd_sc_hd__a221o_2
XFILLER_113_29 VGND VGND VPWR VPWR sky130_fd_sc_hd__decap_3
XTAP_TAPCELL_ROW_39_748 VGND VPWR sky130_fd_sc_hd__tapvpwrvgnd_1
XTAP_TAPCELL_ROW_108_1610 VGND VPWR sky130_fd_sc_hd__tapvpwrvgnd_1
XFILLER_52_701 VGND VGND VPWR VPWR sky130_fd_sc_hd__decap_3
XFILLER_24_414 VGND VGND VPWR VPWR sky130_fd_sc_hd__decap_3
XFILLER_36_285 VGND VGND VPWR VPWR sky130_fd_sc_hd__decap_3
XFILLER_51_211 VGND VGND VPWR VPWR sky130_fd_sc_hd__decap_3
XFILLER_51_255 VGND VGND VPWR VPWR sky130_fd_sc_hd__decap_3
XTAP_TAPCELL_ROW_19_494 VGND VPWR sky130_fd_sc_hd__tapvpwrvgnd_1
XFILLER_11_108 VGND VGND VPWR VPWR sky130_fd_sc_hd__decap_3
XFILLER_11_119 VGND VGND VPWR VPWR sky130_fd_sc_hd__decap_3
X_6705_ _6943_/CLK _6705_/D VGND VGND VPWR VPWR _6705_/Q sky130_fd_sc_hd__dfxtp_2
XFILLER_20_631 VGND VGND VPWR VPWR sky130_fd_sc_hd__decap_3
X_4897_ _4896_/A _4896_/B _4896_/Y _4777_/A VGND VGND VPWR VPWR _4897_/X sky130_fd_sc_hd__o211a_2
X_3917_ _6689_/Q _3925_/A2 _3922_/B1 _6867_/Q VGND VGND VPWR VPWR _3917_/X sky130_fd_sc_hd__a22o_2
XFILLER_20_675 VGND VGND VPWR VPWR sky130_fd_sc_hd__decap_3
XFILLER_22_37 VGND VGND VPWR VPWR sky130_fd_sc_hd__decap_3
X_6636_ _6636_/A VGND VGND VPWR VPWR _6636_/Y sky130_fd_sc_hd__inv_2
X_3848_ _6907_/Q _3886_/A2 _3893_/B1 _6851_/Q VGND VGND VPWR VPWR _3848_/X sky130_fd_sc_hd__a22o_2
X_6567_ _6571_/A VGND VGND VPWR VPWR _6567_/Y sky130_fd_sc_hd__inv_2
X_3779_ _6794_/Q _3886_/B1 _3889_/B1 _6704_/Q _3778_/X VGND VGND VPWR VPWR _3779_/X
+ sky130_fd_sc_hd__a221o_2
XTAP_TAPCELL_ROW_119_1761 VGND VPWR sky130_fd_sc_hd__tapvpwrvgnd_1
XTAP_TAPCELL_ROW_119_1750 VGND VPWR sky130_fd_sc_hd__tapvpwrvgnd_1
XFILLER_105_202 VGND VGND VPWR VPWR sky130_fd_sc_hd__fill_1
X_6498_ _6631_/A VGND VGND VPWR VPWR _6498_/Y sky130_fd_sc_hd__inv_2
XFILLER_105_257 VGND VGND VPWR VPWR sky130_fd_sc_hd__fill_2
XFILLER_105_268 VGND VGND VPWR VPWR sky130_fd_sc_hd__decap_3
XFILLER_87_631 VGND VGND VPWR VPWR sky130_fd_sc_hd__decap_3
XFILLER_59_333 VGND VGND VPWR VPWR sky130_fd_sc_hd__decap_3
XFILLER_59_355 VGND VGND VPWR VPWR sky130_fd_sc_hd__decap_3
XFILLER_86_141 VGND VGND VPWR VPWR sky130_fd_sc_hd__decap_3
XFILLER_87_664 VGND VGND VPWR VPWR sky130_fd_sc_hd__decap_3
X_7119_ _7345_/CLK _7119_/D _6399_/Y VGND VGND VPWR VPWR _7119_/Q sky130_fd_sc_hd__dfrtp_2
XFILLER_101_463 VGND VGND VPWR VPWR sky130_fd_sc_hd__fill_1
XFILLER_19_208 VGND VGND VPWR VPWR sky130_fd_sc_hd__decap_3
XFILLER_47_528 VGND VGND VPWR VPWR sky130_fd_sc_hd__decap_3
XFILLER_86_174 VGND VGND VPWR VPWR sky130_fd_sc_hd__decap_3
XFILLER_87_697 VGND VGND VPWR VPWR sky130_fd_sc_hd__decap_3
XFILLER_101_485 VGND VGND VPWR VPWR sky130_fd_sc_hd__decap_3
XFILLER_59_399 VGND VGND VPWR VPWR sky130_fd_sc_hd__decap_3
XFILLER_27_252 VGND VGND VPWR VPWR sky130_fd_sc_hd__decap_3
XFILLER_55_561 VGND VGND VPWR VPWR sky130_fd_sc_hd__decap_3
XFILLER_62_509 VGND VGND VPWR VPWR sky130_fd_sc_hd__decap_3
XFILLER_15_425 VGND VGND VPWR VPWR sky130_fd_sc_hd__decap_3
XFILLER_42_200 VGND VGND VPWR VPWR sky130_fd_sc_hd__decap_3
XFILLER_43_712 VGND VGND VPWR VPWR sky130_fd_sc_hd__fill_2
XFILLER_55_594 VGND VGND VPWR VPWR sky130_fd_sc_hd__fill_2
XFILLER_63_11 VGND VGND VPWR VPWR sky130_fd_sc_hd__decap_3
XFILLER_63_22 VGND VGND VPWR VPWR sky130_fd_sc_hd__decap_3
XFILLER_63_33 VGND VGND VPWR VPWR sky130_fd_sc_hd__decap_3
XFILLER_82_380 VGND VGND VPWR VPWR sky130_fd_sc_hd__decap_3
XFILLER_15_458 VGND VGND VPWR VPWR sky130_fd_sc_hd__decap_3
XFILLER_42_244 VGND VGND VPWR VPWR sky130_fd_sc_hd__decap_3
XFILLER_63_99 VGND VGND VPWR VPWR sky130_fd_sc_hd__decap_3
XFILLER_11_620 VGND VGND VPWR VPWR sky130_fd_sc_hd__decap_3
XFILLER_42_299 VGND VGND VPWR VPWR sky130_fd_sc_hd__decap_3
XFILLER_11_653 VGND VGND VPWR VPWR sky130_fd_sc_hd__decap_3
XFILLER_11_697 VGND VGND VPWR VPWR sky130_fd_sc_hd__decap_3
XFILLER_6_112 VGND VGND VPWR VPWR sky130_fd_sc_hd__fill_1
XFILLER_7_635 VGND VGND VPWR VPWR sky130_fd_sc_hd__decap_3
XFILLER_7_668 VGND VGND VPWR VPWR sky130_fd_sc_hd__decap_3
XFILLER_7_679 VGND VGND VPWR VPWR sky130_fd_sc_hd__decap_3
XFILLER_109_596 VGND VGND VPWR VPWR sky130_fd_sc_hd__decap_3
XTAP_TAPCELL_ROW_94_1433 VGND VPWR sky130_fd_sc_hd__tapvpwrvgnd_1
XFILLER_88_52 VGND VGND VPWR VPWR sky130_fd_sc_hd__decap_3
XFILLER_97_406 VGND VGND VPWR VPWR sky130_fd_sc_hd__decap_3
XFILLER_2_362 VGND VGND VPWR VPWR sky130_fd_sc_hd__fill_2
XFILLER_2_384 VGND VGND VPWR VPWR sky130_fd_sc_hd__decap_3
XFILLER_69_119 VGND VGND VPWR VPWR sky130_fd_sc_hd__decap_3
XFILLER_78_620 VGND VGND VPWR VPWR sky130_fd_sc_hd__decap_3
XFILLER_88_85 VGND VGND VPWR VPWR sky130_fd_sc_hd__decap_3
XFILLER_97_428 VGND VGND VPWR VPWR sky130_fd_sc_hd__decap_3
XFILLER_77_141 VGND VGND VPWR VPWR sky130_fd_sc_hd__decap_3
XFILLER_77_163 VGND VGND VPWR VPWR sky130_fd_sc_hd__decap_3
XFILLER_78_675 VGND VGND VPWR VPWR sky130_fd_sc_hd__decap_3
XFILLER_92_100 VGND VGND VPWR VPWR sky130_fd_sc_hd__decap_3
XFILLER_93_623 VGND VGND VPWR VPWR sky130_fd_sc_hd__decap_3
XFILLER_65_325 VGND VGND VPWR VPWR sky130_fd_sc_hd__fill_2
XFILLER_92_133 VGND VGND VPWR VPWR sky130_fd_sc_hd__decap_3
XFILLER_93_656 VGND VGND VPWR VPWR sky130_fd_sc_hd__decap_3
XFILLER_34_701 VGND VGND VPWR VPWR sky130_fd_sc_hd__decap_3
XTAP_TAPCELL_ROW_36_707 VGND VPWR sky130_fd_sc_hd__tapvpwrvgnd_1
XFILLER_46_583 VGND VGND VPWR VPWR sky130_fd_sc_hd__fill_1
XFILLER_61_520 VGND VGND VPWR VPWR sky130_fd_sc_hd__fill_1
XFILLER_73_380 VGND VGND VPWR VPWR sky130_fd_sc_hd__decap_3
XFILLER_92_177 VGND VGND VPWR VPWR sky130_fd_sc_hd__decap_3
XFILLER_18_296 VGND VGND VPWR VPWR sky130_fd_sc_hd__decap_3
XFILLER_33_222 VGND VGND VPWR VPWR sky130_fd_sc_hd__fill_2
XFILLER_61_531 VGND VGND VPWR VPWR sky130_fd_sc_hd__decap_3
X_4820_ _5156_/S _5634_/B VGND VGND VPWR VPWR _5010_/A sky130_fd_sc_hd__nand2_2
XFILLER_21_406 VGND VGND VPWR VPWR sky130_fd_sc_hd__decap_3
XFILLER_21_428 VGND VGND VPWR VPWR sky130_fd_sc_hd__decap_3
XFILLER_61_586 VGND VGND VPWR VPWR sky130_fd_sc_hd__fill_2
XTAP_TAPCELL_ROW_16_464 VGND VPWR sky130_fd_sc_hd__tapvpwrvgnd_1
XTAP_TAPCELL_ROW_16_453 VGND VPWR sky130_fd_sc_hd__tapvpwrvgnd_1
XTAP_TAPCELL_ROW_103_1551 VGND VPWR sky130_fd_sc_hd__tapvpwrvgnd_1
XTAP_TAPCELL_ROW_103_1540 VGND VPWR sky130_fd_sc_hd__tapvpwrvgnd_1
XFILLER_33_299 VGND VGND VPWR VPWR sky130_fd_sc_hd__decap_3
X_4751_ _4751_/A _4751_/B VGND VGND VPWR VPWR _4751_/Y sky130_fd_sc_hd__nand2_2
X_4682_ _4928_/B _4682_/B _4960_/B VGND VGND VPWR VPWR _4943_/A sky130_fd_sc_hd__and3b_2
X_3702_ _3702_/A1 _4832_/A _3701_/X VGND VGND VPWR VPWR _7401_/D sky130_fd_sc_hd__o21a_2
X_6421_ _6645_/A VGND VGND VPWR VPWR _6421_/Y sky130_fd_sc_hd__inv_2
X_3633_ _3636_/A _5072_/A _3635_/B _3630_/A VGND VGND VPWR VPWR _3633_/Y sky130_fd_sc_hd__a22oi_2
XFILLER_115_500 VGND VGND VPWR VPWR sky130_fd_sc_hd__decap_3
XFILLER_108_18 VGND VGND VPWR VPWR sky130_fd_sc_hd__decap_3
XFILLER_108_29 VGND VGND VPWR VPWR sky130_fd_sc_hd__decap_3
XFILLER_115_511 VGND VGND VPWR VPWR sky130_fd_sc_hd__decap_3
XFILLER_115_533 VGND VGND VPWR VPWR sky130_fd_sc_hd__decap_3
XFILLER_6_690 VGND VGND VPWR VPWR sky130_fd_sc_hd__decap_3
X_6352_ _6678_/A VGND VGND VPWR VPWR _6352_/Y sky130_fd_sc_hd__inv_2
X_3564_ _5118_/A _5362_/C VGND VGND VPWR VPWR _3564_/X sky130_fd_sc_hd__and2_2
XFILLER_103_706 VGND VGND VPWR VPWR sky130_fd_sc_hd__decap_3
XFILLER_115_566 VGND VGND VPWR VPWR sky130_fd_sc_hd__decap_3
X_6283_ _6621_/A VGND VGND VPWR VPWR _6283_/Y sky130_fd_sc_hd__inv_2
X_3495_ _7028_/Q _4285_/A2 _3494_/X VGND VGND VPWR VPWR _3495_/X sky130_fd_sc_hd__a21o_2
XFILLER_102_216 VGND VGND VPWR VPWR sky130_fd_sc_hd__decap_3
XFILLER_115_599 VGND VGND VPWR VPWR sky130_fd_sc_hd__decap_3
XFILLER_69_620 VGND VGND VPWR VPWR sky130_fd_sc_hd__decap_3
XFILLER_88_439 VGND VGND VPWR VPWR sky130_fd_sc_hd__decap_3
X_5234_ _5234_/A0 _4734_/X _5272_/S VGND VGND VPWR VPWR _7213_/D sky130_fd_sc_hd__mux2_2
XTAP_TAPCELL_ROW_114_1680 VGND VPWR sky130_fd_sc_hd__tapvpwrvgnd_1
XFILLER_69_653 VGND VGND VPWR VPWR sky130_fd_sc_hd__decap_3
X_5165_ _5165_/A _5198_/B VGND VGND VPWR VPWR _7245_/D sky130_fd_sc_hd__and2_2
XFILLER_68_141 VGND VGND VPWR VPWR sky130_fd_sc_hd__decap_3
XFILLER_69_697 VGND VGND VPWR VPWR sky130_fd_sc_hd__decap_3
X_4116_ _7076_/Q _4265_/B VGND VGND VPWR VPWR _4117_/C sky130_fd_sc_hd__or2_2
XFILLER_110_271 VGND VGND VPWR VPWR sky130_fd_sc_hd__decap_3
XFILLER_110_293 VGND VGND VPWR VPWR sky130_fd_sc_hd__decap_3
XFILLER_56_336 VGND VGND VPWR VPWR sky130_fd_sc_hd__decap_3
XFILLER_56_347 VGND VGND VPWR VPWR sky130_fd_sc_hd__decap_3
XFILLER_68_174 VGND VGND VPWR VPWR sky130_fd_sc_hd__decap_3
XFILLER_83_122 VGND VGND VPWR VPWR sky130_fd_sc_hd__fill_1
XFILLER_84_634 VGND VGND VPWR VPWR sky130_fd_sc_hd__decap_3
XFILLER_84_645 VGND VGND VPWR VPWR sky130_fd_sc_hd__decap_3
XFILLER_83_144 VGND VGND VPWR VPWR sky130_fd_sc_hd__decap_3
XFILLER_83_166 VGND VGND VPWR VPWR sky130_fd_sc_hd__fill_2
XFILLER_84_678 VGND VGND VPWR VPWR sky130_fd_sc_hd__decap_3
X_4047_ _7245_/Q _4433_/B _4131_/A2 _7027_/Q _4046_/X VGND VGND VPWR VPWR _4047_/X
+ sky130_fd_sc_hd__a221o_2
XFILLER_17_48 VGND VGND VPWR VPWR sky130_fd_sc_hd__decap_3
XFILLER_24_200 VGND VGND VPWR VPWR sky130_fd_sc_hd__decap_3
XFILLER_25_712 VGND VGND VPWR VPWR sky130_fd_sc_hd__fill_2
XFILLER_83_199 VGND VGND VPWR VPWR sky130_fd_sc_hd__decap_3
XFILLER_52_542 VGND VGND VPWR VPWR sky130_fd_sc_hd__fill_2
XFILLER_40_704 VGND VGND VPWR VPWR sky130_fd_sc_hd__decap_3
XTAP_TAPCELL_ROW_65_1067 VGND VPWR sky130_fd_sc_hd__tapvpwrvgnd_1
X_4949_ _4967_/A _4967_/B VGND VGND VPWR VPWR _4949_/Y sky130_fd_sc_hd__nand2_2
XFILLER_20_461 VGND VGND VPWR VPWR sky130_fd_sc_hd__decap_3
X_6619_ _6651_/A VGND VGND VPWR VPWR _6619_/Y sky130_fd_sc_hd__inv_2
XFILLER_4_605 VGND VGND VPWR VPWR sky130_fd_sc_hd__decap_3
XFILLER_106_533 VGND VGND VPWR VPWR sky130_fd_sc_hd__decap_3
XFILLER_4_638 VGND VGND VPWR VPWR sky130_fd_sc_hd__decap_3
XFILLER_79_417 VGND VGND VPWR VPWR sky130_fd_sc_hd__fill_2
XFILLER_58_88 VGND VGND VPWR VPWR sky130_fd_sc_hd__decap_3
XFILLER_59_152 VGND VGND VPWR VPWR sky130_fd_sc_hd__fill_2
XFILLER_75_601 VGND VGND VPWR VPWR sky130_fd_sc_hd__decap_3
XFILLER_87_461 VGND VGND VPWR VPWR sky130_fd_sc_hd__decap_3
XFILLER_114_50 VGND VGND VPWR VPWR sky130_fd_sc_hd__decap_3
XFILLER_59_196 VGND VGND VPWR VPWR sky130_fd_sc_hd__decap_3
XFILLER_74_100 VGND VGND VPWR VPWR sky130_fd_sc_hd__decap_3
XFILLER_75_623 VGND VGND VPWR VPWR sky130_fd_sc_hd__decap_3
XFILLER_75_656 VGND VGND VPWR VPWR sky130_fd_sc_hd__decap_3
XFILLER_114_83 VGND VGND VPWR VPWR sky130_fd_sc_hd__fill_1
XFILLER_114_94 VGND VGND VPWR VPWR sky130_fd_sc_hd__decap_3
XFILLER_16_701 VGND VGND VPWR VPWR sky130_fd_sc_hd__decap_3
XFILLER_74_133 VGND VGND VPWR VPWR sky130_fd_sc_hd__decap_3
XFILLER_74_144 VGND VGND VPWR VPWR sky130_fd_sc_hd__decap_3
XFILLER_74_43 VGND VGND VPWR VPWR sky130_fd_sc_hd__decap_3
XFILLER_62_317 VGND VGND VPWR VPWR sky130_fd_sc_hd__decap_3
XFILLER_62_339 VGND VGND VPWR VPWR sky130_fd_sc_hd__fill_1
XFILLER_74_177 VGND VGND VPWR VPWR sky130_fd_sc_hd__decap_3
XFILLER_74_65 VGND VGND VPWR VPWR sky130_fd_sc_hd__decap_3
XFILLER_90_637 VGND VGND VPWR VPWR sky130_fd_sc_hd__decap_3
XFILLER_90_648 VGND VGND VPWR VPWR sky130_fd_sc_hd__decap_3
XFILLER_43_531 VGND VGND VPWR VPWR sky130_fd_sc_hd__decap_3
XFILLER_15_266 VGND VGND VPWR VPWR sky130_fd_sc_hd__fill_1
XFILLER_30_203 VGND VGND VPWR VPWR sky130_fd_sc_hd__decap_3
XFILLER_43_564 VGND VGND VPWR VPWR sky130_fd_sc_hd__decap_3
XFILLER_43_575 VGND VGND VPWR VPWR sky130_fd_sc_hd__fill_1
XFILLER_70_361 VGND VGND VPWR VPWR sky130_fd_sc_hd__decap_3
XFILLER_15_299 VGND VGND VPWR VPWR sky130_fd_sc_hd__decap_3
XFILLER_30_214 VGND VGND VPWR VPWR sky130_fd_sc_hd__decap_3
XTAP_TAPCELL_ROW_13_423 VGND VPWR sky130_fd_sc_hd__tapvpwrvgnd_1
XFILLER_30_247 VGND VGND VPWR VPWR sky130_fd_sc_hd__decap_3
XFILLER_30_269 VGND VGND VPWR VPWR sky130_fd_sc_hd__decap_3
XFILLER_90_97 VGND VGND VPWR VPWR sky130_fd_sc_hd__decap_3
XTAP_TAPCELL_ROW_41_776 VGND VPWR sky130_fd_sc_hd__tapvpwrvgnd_1
XTAP_TAPCELL_ROW_41_765 VGND VPWR sky130_fd_sc_hd__tapvpwrvgnd_1
XFILLER_7_443 VGND VGND VPWR VPWR sky130_fd_sc_hd__decap_3
XFILLER_109_360 VGND VGND VPWR VPWR sky130_fd_sc_hd__fill_2
XFILLER_109_393 VGND VGND VPWR VPWR sky130_fd_sc_hd__decap_3
XFILLER_99_95 VGND VGND VPWR VPWR sky130_fd_sc_hd__decap_3
XFILLER_98_704 VGND VGND VPWR VPWR sky130_fd_sc_hd__decap_3
XFILLER_112_514 VGND VGND VPWR VPWR sky130_fd_sc_hd__decap_3
XFILLER_3_671 VGND VGND VPWR VPWR sky130_fd_sc_hd__fill_1
XFILLER_3_682 VGND VGND VPWR VPWR sky130_fd_sc_hd__decap_3
XFILLER_17_3 VGND VGND VPWR VPWR sky130_fd_sc_hd__fill_1
XFILLER_38_336 VGND VGND VPWR VPWR sky130_fd_sc_hd__decap_3
XFILLER_65_111 VGND VGND VPWR VPWR sky130_fd_sc_hd__fill_1
XFILLER_65_122 VGND VGND VPWR VPWR sky130_fd_sc_hd__decap_3
XFILLER_66_623 VGND VGND VPWR VPWR sky130_fd_sc_hd__decap_3
XFILLER_66_645 VGND VGND VPWR VPWR sky130_fd_sc_hd__decap_3
XFILLER_19_550 VGND VGND VPWR VPWR sky130_fd_sc_hd__decap_3
XFILLER_65_155 VGND VGND VPWR VPWR sky130_fd_sc_hd__decap_3
XFILLER_66_678 VGND VGND VPWR VPWR sky130_fd_sc_hd__decap_3
X_6970_ _6983_/CLK _6970_/D VGND VGND VPWR VPWR _6970_/Q sky130_fd_sc_hd__dfxtp_2
XTAP_TAPCELL_ROW_49_876 VGND VPWR sky130_fd_sc_hd__tapvpwrvgnd_1
XTAP_TAPCELL_ROW_49_865 VGND VPWR sky130_fd_sc_hd__tapvpwrvgnd_1
XFILLER_19_561 VGND VGND VPWR VPWR sky130_fd_sc_hd__fill_2
XFILLER_19_583 VGND VGND VPWR VPWR sky130_fd_sc_hd__decap_3
XFILLER_65_188 VGND VGND VPWR VPWR sky130_fd_sc_hd__decap_3
XFILLER_80_103 VGND VGND VPWR VPWR sky130_fd_sc_hd__decap_3
XFILLER_81_626 VGND VGND VPWR VPWR sky130_fd_sc_hd__decap_3
XFILLER_34_542 VGND VGND VPWR VPWR sky130_fd_sc_hd__fill_2
XFILLER_34_553 VGND VGND VPWR VPWR sky130_fd_sc_hd__fill_1
XFILLER_80_136 VGND VGND VPWR VPWR sky130_fd_sc_hd__decap_3
XFILLER_80_147 VGND VGND VPWR VPWR sky130_fd_sc_hd__decap_3
XFILLER_80_158 VGND VGND VPWR VPWR sky130_fd_sc_hd__decap_3
XFILLER_81_659 VGND VGND VPWR VPWR sky130_fd_sc_hd__decap_3
XFILLER_22_704 VGND VGND VPWR VPWR sky130_fd_sc_hd__decap_3
XFILLER_34_575 VGND VGND VPWR VPWR sky130_fd_sc_hd__decap_3
XFILLER_21_225 VGND VGND VPWR VPWR sky130_fd_sc_hd__decap_3
XFILLER_61_383 VGND VGND VPWR VPWR sky130_fd_sc_hd__decap_3
X_4803_ _7003_/Q _4802_/X _4677_/B _5667_/A VGND VGND VPWR VPWR _4804_/B sky130_fd_sc_hd__o211ai_2
XFILLER_119_102 VGND VGND VPWR VPWR sky130_fd_sc_hd__fill_2
XFILLER_21_269 VGND VGND VPWR VPWR sky130_fd_sc_hd__decap_3
X_4734_ _4726_/X _4729_/Y _7007_/D _4836_/S VGND VGND VPWR VPWR _4734_/X sky130_fd_sc_hd__o22a_2
XFILLER_119_113 VGND VGND VPWR VPWR sky130_fd_sc_hd__decap_3
XFILLER_119_124 VGND VGND VPWR VPWR sky130_fd_sc_hd__decap_3
XFILLER_107_308 VGND VGND VPWR VPWR sky130_fd_sc_hd__fill_1
X_4665_ _7005_/Q _4690_/B VGND VGND VPWR VPWR _4665_/X sky130_fd_sc_hd__or2_2
X_7384_ _7388_/CLK _7384_/D _6664_/Y VGND VGND VPWR VPWR _7384_/Q sky130_fd_sc_hd__dfrtp_2
Xhold900 _6829_/Q VGND VGND VPWR VPWR _6829_/D sky130_fd_sc_hd__dlygate4sd3_1
Xhold911 _6866_/Q VGND VGND VPWR VPWR _6866_/D sky130_fd_sc_hd__dlygate4sd3_1
Xhold922 _6812_/Q VGND VGND VPWR VPWR _6812_/D sky130_fd_sc_hd__dlygate4sd3_1
X_6404_ _6533_/A VGND VGND VPWR VPWR _6404_/Y sky130_fd_sc_hd__inv_2
X_3616_ _4614_/C _3616_/B VGND VGND VPWR VPWR _3616_/Y sky130_fd_sc_hd__nand2_2
XFILLER_115_330 VGND VGND VPWR VPWR sky130_fd_sc_hd__decap_3
XFILLER_115_352 VGND VGND VPWR VPWR sky130_fd_sc_hd__decap_3
Xhold933 _6953_/Q VGND VGND VPWR VPWR _6953_/D sky130_fd_sc_hd__dlygate4sd3_1
Xhold944 _7076_/Q VGND VGND VPWR VPWR _7076_/D sky130_fd_sc_hd__dlygate4sd3_1
Xhold955 _7073_/Q VGND VGND VPWR VPWR _7073_/D sky130_fd_sc_hd__dlygate4sd3_1
X_6335_ _6463_/A VGND VGND VPWR VPWR _6335_/Y sky130_fd_sc_hd__inv_2
X_3547_ _3547_/A _3547_/B VGND VGND VPWR VPWR _3547_/Y sky130_fd_sc_hd__nand2_2
XFILLER_115_385 VGND VGND VPWR VPWR sky130_fd_sc_hd__decap_3
XFILLER_88_203 VGND VGND VPWR VPWR sky130_fd_sc_hd__decap_3
Xhold966 _7092_/Q VGND VGND VPWR VPWR _7092_/D sky130_fd_sc_hd__dlygate4sd3_1
Xhold977 _7067_/Q VGND VGND VPWR VPWR _7067_/D sky130_fd_sc_hd__dlygate4sd3_1
Xmax_cap674 _4537_/C VGND VGND VPWR VPWR _3538_/B1 sky130_fd_sc_hd__clkbuf_2
Xhold988 _7080_/Q VGND VGND VPWR VPWR _7080_/D sky130_fd_sc_hd__dlygate4sd3_1
XFILLER_115_396 VGND VGND VPWR VPWR sky130_fd_sc_hd__decap_3
XFILLER_88_236 VGND VGND VPWR VPWR sky130_fd_sc_hd__decap_3
Xhold999 _7109_/Q VGND VGND VPWR VPWR _7109_/D sky130_fd_sc_hd__dlygate4sd3_1
X_6266_ _6671_/A VGND VGND VPWR VPWR _6266_/Y sky130_fd_sc_hd__inv_2
X_3478_ _7216_/Q _3318_/B _4534_/S _7029_/Q _3477_/X VGND VGND VPWR VPWR _3478_/X
+ sky130_fd_sc_hd__a221o_2
XFILLER_69_472 VGND VGND VPWR VPWR sky130_fd_sc_hd__decap_3
XFILLER_76_409 VGND VGND VPWR VPWR sky130_fd_sc_hd__fill_2
X_5217_ _5217_/A _5225_/B VGND VGND VPWR VPWR _7220_/D sky130_fd_sc_hd__and2_2
XFILLER_111_591 VGND VGND VPWR VPWR sky130_fd_sc_hd__decap_3
XFILLER_29_325 VGND VGND VPWR VPWR sky130_fd_sc_hd__decap_3
XFILLER_57_623 VGND VGND VPWR VPWR sky130_fd_sc_hd__decap_3
X_5148_ _5144_/A _5071_/A _3618_/C _3540_/X VGND VGND VPWR VPWR _5148_/X sky130_fd_sc_hd__a211o_2
XFILLER_29_358 VGND VGND VPWR VPWR sky130_fd_sc_hd__decap_3
XFILLER_56_144 VGND VGND VPWR VPWR sky130_fd_sc_hd__decap_3
XFILLER_57_656 VGND VGND VPWR VPWR sky130_fd_sc_hd__decap_3
XFILLER_84_453 VGND VGND VPWR VPWR sky130_fd_sc_hd__decap_3
X_5079_ _5156_/S _6987_/D _5078_/X VGND VGND VPWR VPWR _5079_/X sky130_fd_sc_hd__o21a_2
XFILLER_72_637 VGND VGND VPWR VPWR sky130_fd_sc_hd__decap_3
XFILLER_72_648 VGND VGND VPWR VPWR sky130_fd_sc_hd__decap_3
XFILLER_37_380 VGND VGND VPWR VPWR sky130_fd_sc_hd__decap_3
XFILLER_71_136 VGND VGND VPWR VPWR sky130_fd_sc_hd__decap_3
XFILLER_71_147 VGND VGND VPWR VPWR sky130_fd_sc_hd__decap_3
XFILLER_25_564 VGND VGND VPWR VPWR sky130_fd_sc_hd__fill_1
XFILLER_25_586 VGND VGND VPWR VPWR sky130_fd_sc_hd__decap_3
XFILLER_40_501 VGND VGND VPWR VPWR sky130_fd_sc_hd__decap_3
XFILLER_44_68 VGND VGND VPWR VPWR sky130_fd_sc_hd__decap_3
XFILLER_71_169 VGND VGND VPWR VPWR sky130_fd_sc_hd__decap_3
XFILLER_12_225 VGND VGND VPWR VPWR sky130_fd_sc_hd__decap_3
XFILLER_40_545 VGND VGND VPWR VPWR sky130_fd_sc_hd__decap_3
XFILLER_52_383 VGND VGND VPWR VPWR sky130_fd_sc_hd__decap_3
XFILLER_80_681 VGND VGND VPWR VPWR sky130_fd_sc_hd__decap_3
XFILLER_100_41 VGND VGND VPWR VPWR sky130_fd_sc_hd__decap_3
XFILLER_100_85 VGND VGND VPWR VPWR sky130_fd_sc_hd__decap_3
XFILLER_40_589 VGND VGND VPWR VPWR sky130_fd_sc_hd__fill_1
XFILLER_60_23 VGND VGND VPWR VPWR sky130_fd_sc_hd__decap_3
XFILLER_60_45 VGND VGND VPWR VPWR sky130_fd_sc_hd__fill_2
XFILLER_20_280 VGND VGND VPWR VPWR sky130_fd_sc_hd__decap_3
XFILLER_20_291 VGND VGND VPWR VPWR sky130_fd_sc_hd__decap_3
XFILLER_60_56 VGND VGND VPWR VPWR sky130_fd_sc_hd__decap_3
XTAP_TAPCELL_ROW_78_1236 VGND VPWR sky130_fd_sc_hd__tapvpwrvgnd_1
XFILLER_109_72 VGND VGND VPWR VPWR sky130_fd_sc_hd__decap_3
XFILLER_106_374 VGND VGND VPWR VPWR sky130_fd_sc_hd__decap_3
XFILLER_109_94 VGND VGND VPWR VPWR sky130_fd_sc_hd__decap_3
XFILLER_79_225 VGND VGND VPWR VPWR sky130_fd_sc_hd__decap_3
XFILLER_79_258 VGND VGND VPWR VPWR sky130_fd_sc_hd__decap_3
XFILLER_0_685 VGND VGND VPWR VPWR sky130_fd_sc_hd__decap_3
XFILLER_47_111 VGND VGND VPWR VPWR sky130_fd_sc_hd__fill_1
XFILLER_47_122 VGND VGND VPWR VPWR sky130_fd_sc_hd__decap_3
XFILLER_48_623 VGND VGND VPWR VPWR sky130_fd_sc_hd__decap_3
XFILLER_48_645 VGND VGND VPWR VPWR sky130_fd_sc_hd__decap_3
XFILLER_48_678 VGND VGND VPWR VPWR sky130_fd_sc_hd__decap_3
XFILLER_75_442 VGND VGND VPWR VPWR sky130_fd_sc_hd__decap_3
XFILLER_85_75 VGND VGND VPWR VPWR sky130_fd_sc_hd__decap_3
XTAP_TAPCELL_ROW_89_1365 VGND VPWR sky130_fd_sc_hd__tapvpwrvgnd_1
XFILLER_35_328 VGND VGND VPWR VPWR sky130_fd_sc_hd__decap_3
XFILLER_62_114 VGND VGND VPWR VPWR sky130_fd_sc_hd__decap_3
XFILLER_63_626 VGND VGND VPWR VPWR sky130_fd_sc_hd__decap_3
XTAP_TAPCELL_ROW_89_1376 VGND VPWR sky130_fd_sc_hd__tapvpwrvgnd_1
XFILLER_18_91 VGND VGND VPWR VPWR sky130_fd_sc_hd__decap_3
XFILLER_28_380 VGND VGND VPWR VPWR sky130_fd_sc_hd__decap_3
XFILLER_47_199 VGND VGND VPWR VPWR sky130_fd_sc_hd__decap_3
XFILLER_62_147 VGND VGND VPWR VPWR sky130_fd_sc_hd__decap_3
XFILLER_63_659 VGND VGND VPWR VPWR sky130_fd_sc_hd__decap_3
XTAP_TAPCELL_ROW_46_835 VGND VPWR sky130_fd_sc_hd__tapvpwrvgnd_1
XFILLER_16_575 VGND VGND VPWR VPWR sky130_fd_sc_hd__decap_3
XFILLER_43_350 VGND VGND VPWR VPWR sky130_fd_sc_hd__decap_3
XFILLER_50_309 VGND VGND VPWR VPWR sky130_fd_sc_hd__decap_3
XTAP_TAPCELL_ROW_26_581 VGND VPWR sky130_fd_sc_hd__tapvpwrvgnd_1
XTAP_TAPCELL_ROW_100_1510 VGND VPWR sky130_fd_sc_hd__tapvpwrvgnd_1
XFILLER_31_556 VGND VGND VPWR VPWR sky130_fd_sc_hd__fill_1
XFILLER_86_6 VGND VGND VPWR VPWR sky130_fd_sc_hd__fill_1
XFILLER_31_589 VGND VGND VPWR VPWR sky130_fd_sc_hd__decap_3
XFILLER_117_606 VGND VGND VPWR VPWR sky130_fd_sc_hd__decap_3
XFILLER_117_617 VGND VGND VPWR VPWR sky130_fd_sc_hd__decap_3
XFILLER_7_284 VGND VGND VPWR VPWR sky130_fd_sc_hd__decap_3
X_4450_ _4451_/A _4451_/B VGND VGND VPWR VPWR _4452_/A sky130_fd_sc_hd__and2_2
X_4381_ _4381_/A _4381_/B VGND VGND VPWR VPWR _4967_/B sky130_fd_sc_hd__nand2_2
X_3401_ _4467_/A _3519_/B _5294_/A _3330_/Y VGND VGND VPWR VPWR _3401_/X sky130_fd_sc_hd__a31o_4
X_3332_ _4467_/A _3332_/B VGND VGND VPWR VPWR _3341_/A sky130_fd_sc_hd__nand2_2
XFILLER_3_490 VGND VGND VPWR VPWR sky130_fd_sc_hd__decap_3
XFILLER_86_707 VGND VGND VPWR VPWR sky130_fd_sc_hd__decap_3
XFILLER_98_545 VGND VGND VPWR VPWR sky130_fd_sc_hd__decap_3
XFILLER_112_355 VGND VGND VPWR VPWR sky130_fd_sc_hd__decap_3
XFILLER_112_377 VGND VGND VPWR VPWR sky130_fd_sc_hd__fill_2
XFILLER_39_601 VGND VGND VPWR VPWR sky130_fd_sc_hd__decap_3
XTAP_TAPCELL_ROW_111_1650 VGND VPWR sky130_fd_sc_hd__tapvpwrvgnd_1
XFILLER_112_388 VGND VGND VPWR VPWR sky130_fd_sc_hd__decap_3
XFILLER_38_100 VGND VGND VPWR VPWR sky130_fd_sc_hd__decap_3
XFILLER_39_623 VGND VGND VPWR VPWR sky130_fd_sc_hd__decap_3
XFILLER_85_228 VGND VGND VPWR VPWR sky130_fd_sc_hd__decap_3
X_5002_ _5003_/A _5003_/B _4948_/A VGND VGND VPWR VPWR _5002_/Y sky130_fd_sc_hd__a21oi_2
XFILLER_38_133 VGND VGND VPWR VPWR sky130_fd_sc_hd__decap_3
XFILLER_38_144 VGND VGND VPWR VPWR sky130_fd_sc_hd__decap_3
XFILLER_39_656 VGND VGND VPWR VPWR sky130_fd_sc_hd__decap_3
XFILLER_66_464 VGND VGND VPWR VPWR sky130_fd_sc_hd__decap_3
XFILLER_38_188 VGND VGND VPWR VPWR sky130_fd_sc_hd__decap_3
XFILLER_54_615 VGND VGND VPWR VPWR sky130_fd_sc_hd__decap_3
XFILLER_53_147 VGND VGND VPWR VPWR sky130_fd_sc_hd__decap_3
XFILLER_54_648 VGND VGND VPWR VPWR sky130_fd_sc_hd__decap_3
X_6953_ clkload9/A _6953_/D VGND VGND VPWR VPWR _6953_/Q sky130_fd_sc_hd__dfxtp_2
XFILLER_53_169 VGND VGND VPWR VPWR sky130_fd_sc_hd__fill_2
XFILLER_81_478 VGND VGND VPWR VPWR sky130_fd_sc_hd__fill_2
Xclkbuf_3_5__f_clk clkbuf_0_clk/X VGND VGND VPWR VPWR clkload1/A sky130_fd_sc_hd__clkbuf_16
X_6884_ _6944_/CLK _6884_/D VGND VGND VPWR VPWR _6884_/Q sky130_fd_sc_hd__dfxtp_2
XFILLER_22_523 VGND VGND VPWR VPWR sky130_fd_sc_hd__decap_3
XFILLER_62_681 VGND VGND VPWR VPWR sky130_fd_sc_hd__decap_3
XTAP_TAPCELL_ROW_62_1037 VGND VPWR sky130_fd_sc_hd__tapvpwrvgnd_1
XFILLER_10_707 VGND VGND VPWR VPWR sky130_fd_sc_hd__decap_3
XFILLER_61_191 VGND VGND VPWR VPWR sky130_fd_sc_hd__decap_3
XFILLER_22_589 VGND VGND VPWR VPWR sky130_fd_sc_hd__decap_3
X_5697_ _7354_/Q _5697_/A1 _5721_/S VGND VGND VPWR VPWR _6698_/D sky130_fd_sc_hd__mux2_2
XFILLER_107_116 VGND VGND VPWR VPWR sky130_fd_sc_hd__decap_3
XFILLER_108_628 VGND VGND VPWR VPWR sky130_fd_sc_hd__decap_3
X_4648_ _4648_/A VGND VGND VPWR VPWR _4648_/Y sky130_fd_sc_hd__inv_2
XFILLER_107_149 VGND VGND VPWR VPWR sky130_fd_sc_hd__decap_3
Xhold730 _6838_/Q VGND VGND VPWR VPWR _6838_/D sky130_fd_sc_hd__dlygate4sd3_1
XFILLER_116_672 VGND VGND VPWR VPWR sky130_fd_sc_hd__decap_3
X_7367_ _7406_/CLK _7367_/D _6647_/Y VGND VGND VPWR VPWR _7367_/Q sky130_fd_sc_hd__dfrtp_2
Xhold741 _6938_/Q VGND VGND VPWR VPWR _6938_/D sky130_fd_sc_hd__dlygate4sd3_1
Xhold752 _6847_/Q VGND VGND VPWR VPWR _6847_/D sky130_fd_sc_hd__dlygate4sd3_1
Xhold763 _6791_/Q VGND VGND VPWR VPWR _6791_/D sky130_fd_sc_hd__dlygate4sd3_1
X_4579_ _4579_/A _4593_/B VGND VGND VPWR VPWR _7291_/D sky130_fd_sc_hd__and2_2
XFILLER_1_449 VGND VGND VPWR VPWR sky130_fd_sc_hd__fill_2
X_7298_ _7333_/CLK _7298_/D _6578_/Y VGND VGND VPWR VPWR _7298_/Q sky130_fd_sc_hd__dfrtp_2
Xhold774 _6873_/Q VGND VGND VPWR VPWR _6873_/D sky130_fd_sc_hd__dlygate4sd3_1
Xhold785 _6741_/Q VGND VGND VPWR VPWR _6741_/D sky130_fd_sc_hd__dlygate4sd3_1
Xhold796 _6753_/Q VGND VGND VPWR VPWR _6753_/D sky130_fd_sc_hd__dlygate4sd3_1
X_6318_ _6672_/A VGND VGND VPWR VPWR _6318_/Y sky130_fd_sc_hd__inv_2
XTAP_TAPCELL_ROW_73_1166 VGND VPWR sky130_fd_sc_hd__tapvpwrvgnd_1
XFILLER_103_377 VGND VGND VPWR VPWR sky130_fd_sc_hd__decap_3
XFILLER_89_567 VGND VGND VPWR VPWR sky130_fd_sc_hd__fill_2
XFILLER_89_578 VGND VGND VPWR VPWR sky130_fd_sc_hd__fill_2
XFILLER_103_399 VGND VGND VPWR VPWR sky130_fd_sc_hd__decap_3
XFILLER_76_228 VGND VGND VPWR VPWR sky130_fd_sc_hd__decap_3
XFILLER_17_317 VGND VGND VPWR VPWR sky130_fd_sc_hd__decap_3
XFILLER_45_626 VGND VGND VPWR VPWR sky130_fd_sc_hd__decap_3
XFILLER_84_272 VGND VGND VPWR VPWR sky130_fd_sc_hd__decap_3
XFILLER_29_199 VGND VGND VPWR VPWR sky130_fd_sc_hd__decap_3
XFILLER_45_659 VGND VGND VPWR VPWR sky130_fd_sc_hd__decap_3
XFILLER_72_456 VGND VGND VPWR VPWR sky130_fd_sc_hd__fill_2
XFILLER_32_309 VGND VGND VPWR VPWR sky130_fd_sc_hd__decap_3
XFILLER_44_158 VGND VGND VPWR VPWR sky130_fd_sc_hd__decap_3
XFILLER_72_489 VGND VGND VPWR VPWR sky130_fd_sc_hd__decap_3
XFILLER_111_51 VGND VGND VPWR VPWR sky130_fd_sc_hd__decap_3
XFILLER_25_383 VGND VGND VPWR VPWR sky130_fd_sc_hd__decap_3
XFILLER_111_84 VGND VGND VPWR VPWR sky130_fd_sc_hd__decap_3
XFILLER_13_567 VGND VGND VPWR VPWR sky130_fd_sc_hd__decap_3
XFILLER_71_33 VGND VGND VPWR VPWR sky130_fd_sc_hd__decap_3
XTAP_TAPCELL_ROW_23_540 VGND VPWR sky130_fd_sc_hd__tapvpwrvgnd_1
XFILLER_71_77 VGND VGND VPWR VPWR sky130_fd_sc_hd__fill_2
XFILLER_71_99 VGND VGND VPWR VPWR sky130_fd_sc_hd__decap_3
XTAP_TAPCELL_ROW_23_551 VGND VPWR sky130_fd_sc_hd__tapvpwrvgnd_1
XTAP_TAPCELL_ROW_51_893 VGND VPWR sky130_fd_sc_hd__tapvpwrvgnd_1
XFILLER_5_700 VGND VGND VPWR VPWR sky130_fd_sc_hd__decap_3
XFILLER_107_650 VGND VGND VPWR VPWR sky130_fd_sc_hd__decap_3
XFILLER_113_119 VGND VGND VPWR VPWR sky130_fd_sc_hd__decap_3
XFILLER_4_265 VGND VGND VPWR VPWR sky130_fd_sc_hd__decap_3
XFILLER_107_694 VGND VGND VPWR VPWR sky130_fd_sc_hd__decap_3
XFILLER_68_707 VGND VGND VPWR VPWR sky130_fd_sc_hd__decap_3
XFILLER_67_228 VGND VGND VPWR VPWR sky130_fd_sc_hd__fill_2
XFILLER_67_239 VGND VGND VPWR VPWR sky130_fd_sc_hd__fill_2
XFILLER_95_526 VGND VGND VPWR VPWR sky130_fd_sc_hd__decap_3
XFILLER_95_537 VGND VGND VPWR VPWR sky130_fd_sc_hd__decap_3
XFILLER_96_63 VGND VGND VPWR VPWR sky130_fd_sc_hd__decap_3
XFILLER_96_74 VGND VGND VPWR VPWR sky130_fd_sc_hd__decap_3
XFILLER_96_85 VGND VGND VPWR VPWR sky130_fd_sc_hd__decap_3
XFILLER_36_604 VGND VGND VPWR VPWR sky130_fd_sc_hd__decap_3
XFILLER_36_637 VGND VGND VPWR VPWR sky130_fd_sc_hd__decap_3
XFILLER_48_475 VGND VGND VPWR VPWR sky130_fd_sc_hd__fill_1
XTAP_TAPCELL_ROW_59_993 VGND VPWR sky130_fd_sc_hd__tapvpwrvgnd_1
XFILLER_35_125 VGND VGND VPWR VPWR sky130_fd_sc_hd__decap_3
XFILLER_35_136 VGND VGND VPWR VPWR sky130_fd_sc_hd__decap_3
XFILLER_36_648 VGND VGND VPWR VPWR sky130_fd_sc_hd__decap_3
XFILLER_63_434 VGND VGND VPWR VPWR sky130_fd_sc_hd__fill_2
XFILLER_75_294 VGND VGND VPWR VPWR sky130_fd_sc_hd__decap_3
Xplace412 _4914_/S VGND VGND VPWR VPWR _4865_/S sky130_fd_sc_hd__buf_2
Xplace401 _4272_/B VGND VGND VPWR VPWR _4394_/B sky130_fd_sc_hd__buf_2
XPHY_EDGE_ROW_11_Left_131 VGND VGND VPWR VPWR sky130_fd_sc_hd__decap_3
XFILLER_23_309 VGND VGND VPWR VPWR sky130_fd_sc_hd__decap_3
XFILLER_51_629 VGND VGND VPWR VPWR sky130_fd_sc_hd__decap_3
XFILLER_63_478 VGND VGND VPWR VPWR sky130_fd_sc_hd__fill_1
Xplace456 _4300_/B VGND VGND VPWR VPWR _4419_/A2 sky130_fd_sc_hd__buf_2
Xplace445 _4606_/A VGND VGND VPWR VPWR _5642_/A sky130_fd_sc_hd__buf_2
Xplace434 _3442_/A VGND VGND VPWR VPWR _3857_/A2 sky130_fd_sc_hd__buf_2
Xplace423 _4347_/C1 VGND VGND VPWR VPWR _4248_/A sky130_fd_sc_hd__buf_2
XFILLER_44_681 VGND VGND VPWR VPWR sky130_fd_sc_hd__decap_3
XFILLER_50_128 VGND VGND VPWR VPWR sky130_fd_sc_hd__decap_3
XFILLER_90_286 VGND VGND VPWR VPWR sky130_fd_sc_hd__decap_3
Xplace489 _5156_/S VGND VGND VPWR VPWR _4836_/S sky130_fd_sc_hd__buf_2
Xplace478 _3975_/S VGND VGND VPWR VPWR _3952_/S sky130_fd_sc_hd__buf_2
Xplace467 _4261_/A2 VGND VGND VPWR VPWR _4181_/B1 sky130_fd_sc_hd__buf_2
XFILLER_31_342 VGND VGND VPWR VPWR sky130_fd_sc_hd__decap_3
X_3881_ _6724_/Q _3906_/A2 _3911_/B1 _6719_/Q VGND VGND VPWR VPWR _3881_/X sky130_fd_sc_hd__a22o_2
XFILLER_31_375 VGND VGND VPWR VPWR sky130_fd_sc_hd__decap_3
XFILLER_84_3 VGND VGND VPWR VPWR sky130_fd_sc_hd__decap_3
XFILLER_8_560 VGND VGND VPWR VPWR sky130_fd_sc_hd__decap_3
XFILLER_105_609 VGND VGND VPWR VPWR sky130_fd_sc_hd__decap_3
X_7221_ _7313_/CLK _7221_/D _6501_/Y VGND VGND VPWR VPWR _7221_/Q sky130_fd_sc_hd__dfrtp_2
XPHY_EDGE_ROW_20_Left_140 VGND VGND VPWR VPWR sky130_fd_sc_hd__decap_3
XFILLER_104_119 VGND VGND VPWR VPWR sky130_fd_sc_hd__fill_2
X_4433_ _7239_/Q _4433_/B VGND VGND VPWR VPWR _4433_/X sky130_fd_sc_hd__and2_2
XFILLER_113_620 VGND VGND VPWR VPWR sky130_fd_sc_hd__decap_3
XFILLER_116_18 VGND VGND VPWR VPWR sky130_fd_sc_hd__decap_3
XFILLER_116_29 VGND VGND VPWR VPWR sky130_fd_sc_hd__decap_3
X_7152_ _7344_/CLK _7152_/D _6432_/Y VGND VGND VPWR VPWR _7152_/Q sky130_fd_sc_hd__dfrtp_2
X_4364_ _4364_/A _4364_/B VGND VGND VPWR VPWR _4364_/Y sky130_fd_sc_hd__nor2_2
XFILLER_113_653 VGND VGND VPWR VPWR sky130_fd_sc_hd__decap_3
XFILLER_58_206 VGND VGND VPWR VPWR sky130_fd_sc_hd__decap_3
XFILLER_86_515 VGND VGND VPWR VPWR sky130_fd_sc_hd__decap_3
X_7083_ _7086_/CLK _7083_/D _6363_/Y VGND VGND VPWR VPWR _7083_/Q sky130_fd_sc_hd__dfrtp_2
X_4295_ _3607_/B _4295_/B VGND VGND VPWR VPWR _4295_/X sky130_fd_sc_hd__and2b_2
XFILLER_112_163 VGND VGND VPWR VPWR sky130_fd_sc_hd__decap_3
XFILLER_113_697 VGND VGND VPWR VPWR sky130_fd_sc_hd__decap_3
XFILLER_58_239 VGND VGND VPWR VPWR sky130_fd_sc_hd__decap_3
XFILLER_98_397 VGND VGND VPWR VPWR sky130_fd_sc_hd__decap_3
XFILLER_100_336 VGND VGND VPWR VPWR sky130_fd_sc_hd__decap_3
XFILLER_100_369 VGND VGND VPWR VPWR sky130_fd_sc_hd__decap_3
XFILLER_39_442 VGND VGND VPWR VPWR sky130_fd_sc_hd__decap_3
XFILLER_26_103 VGND VGND VPWR VPWR sky130_fd_sc_hd__decap_3
XFILLER_27_615 VGND VGND VPWR VPWR sky130_fd_sc_hd__fill_1
XFILLER_27_626 VGND VGND VPWR VPWR sky130_fd_sc_hd__decap_3
XFILLER_82_710 VGND VGND VPWR VPWR sky130_fd_sc_hd__decap_3
XFILLER_27_659 VGND VGND VPWR VPWR sky130_fd_sc_hd__decap_3
XFILLER_81_220 VGND VGND VPWR VPWR sky130_fd_sc_hd__decap_3
XFILLER_14_309 VGND VGND VPWR VPWR sky130_fd_sc_hd__decap_3
XFILLER_42_618 VGND VGND VPWR VPWR sky130_fd_sc_hd__decap_3
XFILLER_81_242 VGND VGND VPWR VPWR sky130_fd_sc_hd__decap_3
X_6936_ clkload9/A _6936_/D VGND VGND VPWR VPWR _6936_/Q sky130_fd_sc_hd__dfxtp_2
XTAP_TAPCELL_ROW_1_268 VGND VPWR sky130_fd_sc_hd__tapvpwrvgnd_1
XFILLER_50_651 VGND VGND VPWR VPWR sky130_fd_sc_hd__decap_3
X_6867_ _6923_/CLK _6867_/D VGND VGND VPWR VPWR _6867_/Q sky130_fd_sc_hd__dfxtp_2
XFILLER_50_684 VGND VGND VPWR VPWR sky130_fd_sc_hd__decap_3
X_6798_ _6943_/CLK _6798_/D VGND VGND VPWR VPWR _6798_/Q sky130_fd_sc_hd__dfxtp_2
XFILLER_10_548 VGND VGND VPWR VPWR sky130_fd_sc_hd__decap_3
XTAP_TAPCELL_ROW_20_510 VGND VPWR sky130_fd_sc_hd__tapvpwrvgnd_1
XFILLER_108_447 VGND VGND VPWR VPWR sky130_fd_sc_hd__fill_2
XFILLER_108_469 VGND VGND VPWR VPWR sky130_fd_sc_hd__decap_3
XFILLER_104_631 VGND VGND VPWR VPWR sky130_fd_sc_hd__decap_3
XTAP_TAPCELL_ROW_9_368 VGND VPWR sky130_fd_sc_hd__tapvpwrvgnd_1
XFILLER_104_675 VGND VGND VPWR VPWR sky130_fd_sc_hd__decap_3
XFILLER_1_268 VGND VGND VPWR VPWR sky130_fd_sc_hd__decap_3
XFILLER_49_228 VGND VGND VPWR VPWR sky130_fd_sc_hd__decap_3
XFILLER_106_95 VGND VGND VPWR VPWR sky130_fd_sc_hd__decap_3
XFILLER_92_507 VGND VGND VPWR VPWR sky130_fd_sc_hd__decap_3
XFILLER_18_604 VGND VGND VPWR VPWR sky130_fd_sc_hd__decap_3
XFILLER_66_55 VGND VGND VPWR VPWR sky130_fd_sc_hd__decap_3
XFILLER_66_88 VGND VGND VPWR VPWR sky130_fd_sc_hd__decap_3
Xhold1260 _7160_/Q VGND VGND VPWR VPWR _5342_/A0 sky130_fd_sc_hd__dlygate4sd3_1
XFILLER_18_637 VGND VGND VPWR VPWR sky130_fd_sc_hd__decap_3
XFILLER_18_648 VGND VGND VPWR VPWR sky130_fd_sc_hd__decap_3
Xhold1271 _7153_/Q VGND VGND VPWR VPWR _5356_/A0 sky130_fd_sc_hd__dlygate4sd3_1
Xhold1282 _7188_/Q VGND VGND VPWR VPWR _5283_/B2 sky130_fd_sc_hd__dlygate4sd3_1
Xhold1293 _7234_/Q VGND VGND VPWR VPWR _5188_/A sky130_fd_sc_hd__dlygate4sd3_1
XTAP_TAPCELL_ROW_86_1335 VGND VPWR sky130_fd_sc_hd__tapvpwrvgnd_1
XTAP_TAPCELL_ROW_28_610 VGND VPWR sky130_fd_sc_hd__tapvpwrvgnd_1
XFILLER_72_264 VGND VGND VPWR VPWR sky130_fd_sc_hd__decap_3
XTAP_TAPCELL_ROW_56_963 VGND VPWR sky130_fd_sc_hd__tapvpwrvgnd_1
XTAP_TAPCELL_ROW_56_952 VGND VPWR sky130_fd_sc_hd__tapvpwrvgnd_1
XFILLER_26_681 VGND VGND VPWR VPWR sky130_fd_sc_hd__decap_3
XFILLER_32_128 VGND VGND VPWR VPWR sky130_fd_sc_hd__decap_3
XFILLER_33_629 VGND VGND VPWR VPWR sky130_fd_sc_hd__decap_3
XFILLER_13_331 VGND VGND VPWR VPWR sky130_fd_sc_hd__decap_3
XFILLER_60_459 VGND VGND VPWR VPWR sky130_fd_sc_hd__decap_3
XFILLER_82_76 VGND VGND VPWR VPWR sky130_fd_sc_hd__decap_3
XFILLER_13_364 VGND VGND VPWR VPWR sky130_fd_sc_hd__decap_3
XFILLER_41_662 VGND VGND VPWR VPWR sky130_fd_sc_hd__decap_3
XFILLER_41_673 VGND VGND VPWR VPWR sky130_fd_sc_hd__decap_3
XFILLER_9_302 VGND VGND VPWR VPWR sky130_fd_sc_hd__decap_3
XFILLER_40_172 VGND VGND VPWR VPWR sky130_fd_sc_hd__decap_3
XFILLER_9_368 VGND VGND VPWR VPWR sky130_fd_sc_hd__decap_3
XFILLER_9_357 VGND VGND VPWR VPWR sky130_fd_sc_hd__decap_3
XFILLER_9_335 VGND VGND VPWR VPWR sky130_fd_sc_hd__fill_1
XFILLER_5_530 VGND VGND VPWR VPWR sky130_fd_sc_hd__decap_3
XTAP_TAPCELL_ROW_97_1475 VGND VPWR sky130_fd_sc_hd__tapvpwrvgnd_1
XFILLER_107_491 VGND VGND VPWR VPWR sky130_fd_sc_hd__decap_3
XFILLER_5_585 VGND VGND VPWR VPWR sky130_fd_sc_hd__decap_3
XFILLER_99_128 VGND VGND VPWR VPWR sky130_fd_sc_hd__decap_3
XFILLER_110_601 VGND VGND VPWR VPWR sky130_fd_sc_hd__decap_3
XFILLER_110_634 VGND VGND VPWR VPWR sky130_fd_sc_hd__decap_3
XFILLER_95_323 VGND VGND VPWR VPWR sky130_fd_sc_hd__decap_3
XFILLER_0_290 VGND VGND VPWR VPWR sky130_fd_sc_hd__fill_2
XFILLER_110_645 VGND VGND VPWR VPWR sky130_fd_sc_hd__decap_3
XFILLER_95_356 VGND VGND VPWR VPWR sky130_fd_sc_hd__decap_3
X_4080_ _4075_/X _4079_/X _4425_/A VGND VGND VPWR VPWR _4451_/B sky130_fd_sc_hd__o21ai_2
XFILLER_110_678 VGND VGND VPWR VPWR sky130_fd_sc_hd__decap_3
XFILLER_55_209 VGND VGND VPWR VPWR sky130_fd_sc_hd__decap_3
XFILLER_64_710 VGND VGND VPWR VPWR sky130_fd_sc_hd__decap_3
XFILLER_95_389 VGND VGND VPWR VPWR sky130_fd_sc_hd__decap_3
XFILLER_48_283 VGND VGND VPWR VPWR sky130_fd_sc_hd__fill_2
XFILLER_48_294 VGND VGND VPWR VPWR sky130_fd_sc_hd__decap_3
XFILLER_76_592 VGND VGND VPWR VPWR sky130_fd_sc_hd__fill_1
XFILLER_24_607 VGND VGND VPWR VPWR sky130_fd_sc_hd__decap_3
XFILLER_91_573 VGND VGND VPWR VPWR sky130_fd_sc_hd__fill_1
X_4982_ _6992_/Q _4982_/B _5009_/A VGND VGND VPWR VPWR _4983_/C sky130_fd_sc_hd__or3_2
XFILLER_32_640 VGND VGND VPWR VPWR sky130_fd_sc_hd__decap_3
XFILLER_32_651 VGND VGND VPWR VPWR sky130_fd_sc_hd__decap_3
X_6721_ clkload3/A _6721_/D VGND VGND VPWR VPWR _6721_/Q sky130_fd_sc_hd__dfxtp_2
X_3933_ _7373_/Q _4476_/A0 _3954_/S VGND VGND VPWR VPWR _7373_/D sky130_fd_sc_hd__mux2_2
XTAP_TAPCELL_ROW_106_1582 VGND VPWR sky130_fd_sc_hd__tapvpwrvgnd_1
XFILLER_32_684 VGND VGND VPWR VPWR sky130_fd_sc_hd__decap_3
X_6652_ _6652_/A VGND VGND VPWR VPWR _6652_/Y sky130_fd_sc_hd__inv_2
X_3864_ _3864_/A0 _3863_/X _3864_/S VGND VGND VPWR VPWR _7385_/D sky130_fd_sc_hd__mux2_2
XTAP_TAPCELL_ROW_34_679 VGND VPWR sky130_fd_sc_hd__tapvpwrvgnd_1
XFILLER_31_172 VGND VGND VPWR VPWR sky130_fd_sc_hd__decap_3
XFILLER_118_701 VGND VGND VPWR VPWR sky130_fd_sc_hd__decap_3
X_6583_ _6647_/A VGND VGND VPWR VPWR _6583_/Y sky130_fd_sc_hd__inv_2
X_3795_ _6971_/Q _3893_/B1 _3883_/B1 _6721_/Q VGND VGND VPWR VPWR _3795_/X sky130_fd_sc_hd__a22o_2
XFILLER_105_406 VGND VGND VPWR VPWR sky130_fd_sc_hd__decap_3
Xoutput610 _3394_/A VGND VGND VPWR VPWR instruction_out[16] sky130_fd_sc_hd__clkdlybuf4s25_1
X_7204_ _7396_/CLK _7204_/D _6484_/Y VGND VGND VPWR VPWR _7204_/Q sky130_fd_sc_hd__dfrtp_2
Xoutput654 _7007_/Q VGND VGND VPWR VPWR pc_out[30] sky130_fd_sc_hd__clkdlybuf4s25_1
Xoutput643 _6997_/Q VGND VGND VPWR VPWR pc_out[20] sky130_fd_sc_hd__clkdlybuf4s25_1
Xoutput632 _6987_/Q VGND VGND VPWR VPWR pc_out[10] sky130_fd_sc_hd__clkdlybuf4s25_1
Xoutput621 _4671_/B VGND VGND VPWR VPWR instruction_out[28] sky130_fd_sc_hd__clkdlybuf4s25_1
X_4416_ _7368_/Q _4416_/A2 _4436_/B1 _7176_/Q _4415_/X VGND VGND VPWR VPWR _4416_/X
+ sky130_fd_sc_hd__a221o_2
X_7135_ _7362_/CLK _7135_/D _6415_/Y VGND VGND VPWR VPWR _7135_/Q sky130_fd_sc_hd__dfrtp_2
X_5396_ _5396_/A0 _4978_/X _5402_/S VGND VGND VPWR VPWR _7135_/D sky130_fd_sc_hd__mux2_2
XFILLER_99_673 VGND VGND VPWR VPWR sky130_fd_sc_hd__decap_3
XFILLER_99_662 VGND VGND VPWR VPWR sky130_fd_sc_hd__decap_3
XFILLER_101_612 VGND VGND VPWR VPWR sky130_fd_sc_hd__fill_1
XFILLER_101_623 VGND VGND VPWR VPWR sky130_fd_sc_hd__decap_3
XFILLER_59_526 VGND VGND VPWR VPWR sky130_fd_sc_hd__decap_3
XFILLER_86_323 VGND VGND VPWR VPWR sky130_fd_sc_hd__decap_3
X_4347_ _7289_/Q _4300_/B _4346_/X _4347_/C1 VGND VGND VPWR VPWR _4347_/X sky130_fd_sc_hd__a211o_2
XTAP_TAPCELL_ROW_70_1136 VGND VPWR sky130_fd_sc_hd__tapvpwrvgnd_1
XTAP_TAPCELL_ROW_6_338 VGND VPWR sky130_fd_sc_hd__tapvpwrvgnd_1
XTAP_TAPCELL_ROW_6_327 VGND VPWR sky130_fd_sc_hd__tapvpwrvgnd_1
XFILLER_100_122 VGND VGND VPWR VPWR sky130_fd_sc_hd__decap_3
XFILLER_101_656 VGND VGND VPWR VPWR sky130_fd_sc_hd__decap_3
X_7066_ _7387_/CLK _7066_/D _6346_/Y VGND VGND VPWR VPWR _7066_/Q sky130_fd_sc_hd__dfrtp_2
X_4278_ _7286_/Q _4528_/B _4285_/B1 _7350_/Q _3556_/A VGND VGND VPWR VPWR _4278_/X
+ sky130_fd_sc_hd__a221o_2
XFILLER_100_144 VGND VGND VPWR VPWR sky130_fd_sc_hd__decap_3
XFILLER_39_261 VGND VGND VPWR VPWR sky130_fd_sc_hd__decap_3
XFILLER_86_378 VGND VGND VPWR VPWR sky130_fd_sc_hd__decap_3
XFILLER_54_253 VGND VGND VPWR VPWR sky130_fd_sc_hd__decap_3
XFILLER_70_713 VGND VGND VPWR VPWR sky130_fd_sc_hd__fill_1
XFILLER_14_106 VGND VGND VPWR VPWR sky130_fd_sc_hd__decap_3
XFILLER_15_629 VGND VGND VPWR VPWR sky130_fd_sc_hd__decap_3
XFILLER_82_573 VGND VGND VPWR VPWR sky130_fd_sc_hd__fill_1
XTAP_TAPCELL_ROW_53_922 VGND VPWR sky130_fd_sc_hd__tapvpwrvgnd_1
X_6919_ _6942_/CLK _6919_/D VGND VGND VPWR VPWR _6919_/Q sky130_fd_sc_hd__dfxtp_2
XFILLER_23_662 VGND VGND VPWR VPWR sky130_fd_sc_hd__decap_3
XFILLER_23_673 VGND VGND VPWR VPWR sky130_fd_sc_hd__decap_3
XTAP_TAPCELL_ROW_81_1276 VGND VPWR sky130_fd_sc_hd__tapvpwrvgnd_1
XTAP_TAPCELL_ROW_81_1265 VGND VPWR sky130_fd_sc_hd__tapvpwrvgnd_1
XFILLER_10_334 VGND VGND VPWR VPWR sky130_fd_sc_hd__decap_3
XFILLER_50_492 VGND VGND VPWR VPWR sky130_fd_sc_hd__decap_3
XFILLER_108_200 VGND VGND VPWR VPWR sky130_fd_sc_hd__decap_3
XFILLER_109_712 VGND VGND VPWR VPWR sky130_fd_sc_hd__fill_2
XFILLER_6_327 VGND VGND VPWR VPWR sky130_fd_sc_hd__decap_3
XFILLER_2_522 VGND VGND VPWR VPWR sky130_fd_sc_hd__decap_3
XFILLER_2_533 VGND VGND VPWR VPWR sky130_fd_sc_hd__decap_3
XFILLER_104_450 VGND VGND VPWR VPWR sky130_fd_sc_hd__decap_3
XFILLER_117_50 VGND VGND VPWR VPWR sky130_fd_sc_hd__decap_3
XFILLER_117_72 VGND VGND VPWR VPWR sky130_fd_sc_hd__decap_3
XFILLER_2_566 VGND VGND VPWR VPWR sky130_fd_sc_hd__decap_3
XFILLER_104_483 VGND VGND VPWR VPWR sky130_fd_sc_hd__decap_3
XFILLER_77_76 VGND VGND VPWR VPWR sky130_fd_sc_hd__decap_3
XFILLER_18_401 VGND VGND VPWR VPWR sky130_fd_sc_hd__decap_3
XFILLER_37_209 VGND VGND VPWR VPWR sky130_fd_sc_hd__decap_3
XFILLER_46_710 VGND VGND VPWR VPWR sky130_fd_sc_hd__decap_3
XFILLER_77_367 VGND VGND VPWR VPWR sky130_fd_sc_hd__decap_3
XFILLER_92_315 VGND VGND VPWR VPWR sky130_fd_sc_hd__decap_3
XFILLER_18_456 VGND VGND VPWR VPWR sky130_fd_sc_hd__decap_3
XFILLER_73_540 VGND VGND VPWR VPWR sky130_fd_sc_hd__decap_3
XFILLER_93_75 VGND VGND VPWR VPWR sky130_fd_sc_hd__decap_3
Xhold1090 _7200_/Q VGND VGND VPWR VPWR _5260_/A0 sky130_fd_sc_hd__dlygate4sd3_1
XFILLER_18_489 VGND VGND VPWR VPWR sky130_fd_sc_hd__decap_3
XFILLER_33_437 VGND VGND VPWR VPWR sky130_fd_sc_hd__decap_3
XFILLER_45_297 VGND VGND VPWR VPWR sky130_fd_sc_hd__fill_1
XFILLER_14_640 VGND VGND VPWR VPWR sky130_fd_sc_hd__decap_3
XFILLER_26_91 VGND VGND VPWR VPWR sky130_fd_sc_hd__decap_3
XFILLER_60_256 VGND VGND VPWR VPWR sky130_fd_sc_hd__fill_1
XFILLER_14_651 VGND VGND VPWR VPWR sky130_fd_sc_hd__decap_3
XFILLER_14_684 VGND VGND VPWR VPWR sky130_fd_sc_hd__decap_3
XFILLER_41_492 VGND VGND VPWR VPWR sky130_fd_sc_hd__fill_2
XTAP_TAPCELL_ROW_31_649 VGND VPWR sky130_fd_sc_hd__tapvpwrvgnd_1
X_3580_ _7033_/Q _4285_/A2 _4285_/B1 _7380_/Q VGND VGND VPWR VPWR _3580_/X sky130_fd_sc_hd__a22o_2
XTAP_TAPCELL_ROW_11_395 VGND VPWR sky130_fd_sc_hd__tapvpwrvgnd_1
XFILLER_5_382 VGND VGND VPWR VPWR sky130_fd_sc_hd__fill_1
XFILLER_47_3 VGND VGND VPWR VPWR sky130_fd_sc_hd__decap_3
XFILLER_87_109 VGND VGND VPWR VPWR sky130_fd_sc_hd__decap_3
X_4201_ _4186_/A _4636_/B _4200_/X VGND VGND VPWR VPWR _4201_/X sky130_fd_sc_hd__o21a_2
XFILLER_96_610 VGND VGND VPWR VPWR sky130_fd_sc_hd__decap_3
XFILLER_110_431 VGND VGND VPWR VPWR sky130_fd_sc_hd__decap_3
XFILLER_68_334 VGND VGND VPWR VPWR sky130_fd_sc_hd__decap_3
XFILLER_95_131 VGND VGND VPWR VPWR sky130_fd_sc_hd__decap_3
XFILLER_96_643 VGND VGND VPWR VPWR sky130_fd_sc_hd__fill_1
XFILLER_96_654 VGND VGND VPWR VPWR sky130_fd_sc_hd__decap_3
X_4132_ _7075_/Q _4102_/B _4432_/B1 _4131_/X VGND VGND VPWR VPWR _4207_/A sky130_fd_sc_hd__o211ai_2
XFILLER_56_529 VGND VGND VPWR VPWR sky130_fd_sc_hd__decap_3
XFILLER_95_175 VGND VGND VPWR VPWR sky130_fd_sc_hd__decap_3
XFILLER_96_687 VGND VGND VPWR VPWR sky130_fd_sc_hd__decap_3
X_4063_ _7116_/Q _4434_/A2 _4434_/B1 _7148_/Q VGND VGND VPWR VPWR _4063_/X sky130_fd_sc_hd__a22o_2
XFILLER_83_337 VGND VGND VPWR VPWR sky130_fd_sc_hd__decap_3
XTAP_TAPCELL_ROW_39_749 VGND VPWR sky130_fd_sc_hd__tapvpwrvgnd_1
XTAP_TAPCELL_ROW_108_1611 VGND VPWR sky130_fd_sc_hd__tapvpwrvgnd_1
XFILLER_83_359 VGND VGND VPWR VPWR sky130_fd_sc_hd__fill_1
XFILLER_24_404 VGND VGND VPWR VPWR sky130_fd_sc_hd__decap_3
XFILLER_52_713 VGND VGND VPWR VPWR sky130_fd_sc_hd__fill_1
XFILLER_64_595 VGND VGND VPWR VPWR sky130_fd_sc_hd__decap_3
XFILLER_91_381 VGND VGND VPWR VPWR sky130_fd_sc_hd__decap_3
XFILLER_51_234 VGND VGND VPWR VPWR sky130_fd_sc_hd__decap_3
X_4965_ _4965_/A0 _4964_/X _5028_/S VGND VGND VPWR VPWR _7264_/D sky130_fd_sc_hd__mux2_2
XTAP_TAPCELL_ROW_19_495 VGND VPWR sky130_fd_sc_hd__tapvpwrvgnd_1
XFILLER_51_267 VGND VGND VPWR VPWR sky130_fd_sc_hd__decap_3
X_6704_ _7313_/CLK _6704_/D VGND VGND VPWR VPWR _6704_/Q sky130_fd_sc_hd__dfxtp_2
XFILLER_20_610 VGND VGND VPWR VPWR sky130_fd_sc_hd__decap_3
XFILLER_20_643 VGND VGND VPWR VPWR sky130_fd_sc_hd__fill_1
X_4896_ _4896_/A _4896_/B VGND VGND VPWR VPWR _4896_/Y sky130_fd_sc_hd__nand2_2
XFILLER_20_654 VGND VGND VPWR VPWR sky130_fd_sc_hd__decap_3
X_6635_ _6635_/A VGND VGND VPWR VPWR _6635_/Y sky130_fd_sc_hd__inv_2
X_3847_ _6946_/Q _3887_/A2 _3887_/B1 _6958_/Q _3846_/X VGND VGND VPWR VPWR _3847_/X
+ sky130_fd_sc_hd__a221o_2
XFILLER_118_531 VGND VGND VPWR VPWR sky130_fd_sc_hd__fill_1
XFILLER_20_687 VGND VGND VPWR VPWR sky130_fd_sc_hd__decap_3
X_6566_ _6593_/A VGND VGND VPWR VPWR _6566_/Y sky130_fd_sc_hd__inv_2
X_3778_ _6930_/Q _3886_/A2 _3887_/B1 _6882_/Q VGND VGND VPWR VPWR _3778_/X sky130_fd_sc_hd__a22o_2
XTAP_TAPCELL_ROW_119_1762 VGND VPWR sky130_fd_sc_hd__tapvpwrvgnd_1
XTAP_TAPCELL_ROW_119_1751 VGND VPWR sky130_fd_sc_hd__tapvpwrvgnd_1
XTAP_TAPCELL_ROW_119_1740 VGND VPWR sky130_fd_sc_hd__tapvpwrvgnd_1
XFILLER_106_704 VGND VGND VPWR VPWR sky130_fd_sc_hd__decap_3
XFILLER_105_225 VGND VGND VPWR VPWR sky130_fd_sc_hd__decap_3
X_6497_ _6593_/A VGND VGND VPWR VPWR _6497_/Y sky130_fd_sc_hd__inv_2
XFILLER_78_109 VGND VGND VPWR VPWR sky130_fd_sc_hd__decap_3
XFILLER_87_610 VGND VGND VPWR VPWR sky130_fd_sc_hd__decap_3
X_5379_ _5379_/A0 _4836_/X _5379_/S VGND VGND VPWR VPWR _7143_/D sky130_fd_sc_hd__mux2_2
XFILLER_86_120 VGND VGND VPWR VPWR sky130_fd_sc_hd__decap_3
XFILLER_87_643 VGND VGND VPWR VPWR sky130_fd_sc_hd__decap_3
X_7118_ _7374_/CLK _7118_/D _6398_/Y VGND VGND VPWR VPWR _7118_/Q sky130_fd_sc_hd__dfrtp_2
XFILLER_99_492 VGND VGND VPWR VPWR sky130_fd_sc_hd__decap_3
XFILLER_59_389 VGND VGND VPWR VPWR sky130_fd_sc_hd__decap_3
XFILLER_74_304 VGND VGND VPWR VPWR sky130_fd_sc_hd__decap_3
XFILLER_74_315 VGND VGND VPWR VPWR sky130_fd_sc_hd__fill_1
XFILLER_86_153 VGND VGND VPWR VPWR sky130_fd_sc_hd__decap_3
XFILLER_87_676 VGND VGND VPWR VPWR sky130_fd_sc_hd__decap_3
X_7049_ _7396_/CLK _7049_/D _6329_/Y VGND VGND VPWR VPWR _7049_/Q sky130_fd_sc_hd__dfrtp_2
XFILLER_101_497 VGND VGND VPWR VPWR sky130_fd_sc_hd__decap_3
XFILLER_28_710 VGND VGND VPWR VPWR sky130_fd_sc_hd__decap_3
XFILLER_74_348 VGND VGND VPWR VPWR sky130_fd_sc_hd__decap_3
XFILLER_86_186 VGND VGND VPWR VPWR sky130_fd_sc_hd__fill_2
XPHY_EDGE_ROW_29_Right_29 VGND VGND VPWR VPWR sky130_fd_sc_hd__decap_3
XFILLER_103_41 VGND VGND VPWR VPWR sky130_fd_sc_hd__decap_3
XFILLER_27_231 VGND VGND VPWR VPWR sky130_fd_sc_hd__decap_3
XFILLER_55_551 VGND VGND VPWR VPWR sky130_fd_sc_hd__decap_3
XFILLER_103_63 VGND VGND VPWR VPWR sky130_fd_sc_hd__decap_3
XFILLER_27_264 VGND VGND VPWR VPWR sky130_fd_sc_hd__decap_3
XFILLER_42_212 VGND VGND VPWR VPWR sky130_fd_sc_hd__decap_3
XFILLER_15_437 VGND VGND VPWR VPWR sky130_fd_sc_hd__decap_3
XFILLER_27_297 VGND VGND VPWR VPWR sky130_fd_sc_hd__decap_3
XFILLER_70_543 VGND VGND VPWR VPWR sky130_fd_sc_hd__decap_3
XFILLER_42_256 VGND VGND VPWR VPWR sky130_fd_sc_hd__decap_3
XFILLER_11_632 VGND VGND VPWR VPWR sky130_fd_sc_hd__decap_3
XFILLER_23_481 VGND VGND VPWR VPWR sky130_fd_sc_hd__decap_3
XFILLER_70_598 VGND VGND VPWR VPWR sky130_fd_sc_hd__decap_3
XFILLER_11_665 VGND VGND VPWR VPWR sky130_fd_sc_hd__decap_3
XFILLER_11_676 VGND VGND VPWR VPWR sky130_fd_sc_hd__decap_3
XFILLER_7_603 VGND VGND VPWR VPWR sky130_fd_sc_hd__decap_3
XPHY_EDGE_ROW_38_Right_38 VGND VGND VPWR VPWR sky130_fd_sc_hd__decap_3
XFILLER_10_186 VGND VGND VPWR VPWR sky130_fd_sc_hd__fill_1
XFILLER_7_647 VGND VGND VPWR VPWR sky130_fd_sc_hd__decap_3
XFILLER_109_564 VGND VGND VPWR VPWR sky130_fd_sc_hd__fill_2
XFILLER_10_197 VGND VGND VPWR VPWR sky130_fd_sc_hd__decap_3
XFILLER_12_82 VGND VGND VPWR VPWR sky130_fd_sc_hd__fill_2
XTAP_TAPCELL_ROW_94_1434 VGND VPWR sky130_fd_sc_hd__tapvpwrvgnd_1
XFILLER_112_707 VGND VGND VPWR VPWR sky130_fd_sc_hd__decap_3
XFILLER_2_341 VGND VGND VPWR VPWR sky130_fd_sc_hd__decap_3
XFILLER_88_64 VGND VGND VPWR VPWR sky130_fd_sc_hd__decap_3
XFILLER_111_228 VGND VGND VPWR VPWR sky130_fd_sc_hd__decap_3
XFILLER_88_97 VGND VGND VPWR VPWR sky130_fd_sc_hd__decap_3
XFILLER_104_280 VGND VGND VPWR VPWR sky130_fd_sc_hd__decap_3
XFILLER_78_632 VGND VGND VPWR VPWR sky130_fd_sc_hd__decap_3
XFILLER_78_654 VGND VGND VPWR VPWR sky130_fd_sc_hd__decap_3
XFILLER_78_687 VGND VGND VPWR VPWR sky130_fd_sc_hd__decap_3
XFILLER_93_613 VGND VGND VPWR VPWR sky130_fd_sc_hd__decap_3
XPHY_EDGE_ROW_47_Right_47 VGND VGND VPWR VPWR sky130_fd_sc_hd__decap_3
XFILLER_65_337 VGND VGND VPWR VPWR sky130_fd_sc_hd__decap_3
XFILLER_92_112 VGND VGND VPWR VPWR sky130_fd_sc_hd__decap_3
XFILLER_93_635 VGND VGND VPWR VPWR sky130_fd_sc_hd__decap_3
XFILLER_18_242 VGND VGND VPWR VPWR sky130_fd_sc_hd__fill_1
XFILLER_92_156 VGND VGND VPWR VPWR sky130_fd_sc_hd__decap_3
XFILLER_93_668 VGND VGND VPWR VPWR sky130_fd_sc_hd__decap_3
XFILLER_93_679 VGND VGND VPWR VPWR sky130_fd_sc_hd__decap_3
XTAP_TAPCELL_ROW_36_708 VGND VPWR sky130_fd_sc_hd__tapvpwrvgnd_1
XFILLER_18_253 VGND VGND VPWR VPWR sky130_fd_sc_hd__fill_2
XFILLER_18_264 VGND VGND VPWR VPWR sky130_fd_sc_hd__decap_3
XFILLER_33_201 VGND VGND VPWR VPWR sky130_fd_sc_hd__decap_3
XFILLER_34_713 VGND VGND VPWR VPWR sky130_fd_sc_hd__fill_1
XFILLER_46_595 VGND VGND VPWR VPWR sky130_fd_sc_hd__decap_3
XFILLER_80_318 VGND VGND VPWR VPWR sky130_fd_sc_hd__decap_3
XFILLER_33_234 VGND VGND VPWR VPWR sky130_fd_sc_hd__fill_1
XFILLER_33_245 VGND VGND VPWR VPWR sky130_fd_sc_hd__decap_3
XFILLER_61_554 VGND VGND VPWR VPWR sky130_fd_sc_hd__decap_3
XFILLER_21_418 VGND VGND VPWR VPWR sky130_fd_sc_hd__fill_2
XFILLER_61_576 VGND VGND VPWR VPWR sky130_fd_sc_hd__fill_2
XTAP_TAPCELL_ROW_16_454 VGND VPWR sky130_fd_sc_hd__tapvpwrvgnd_1
XTAP_TAPCELL_ROW_103_1541 VGND VPWR sky130_fd_sc_hd__tapvpwrvgnd_1
X_4750_ _5647_/A _4750_/B _4750_/C VGND VGND VPWR VPWR _4751_/B sky130_fd_sc_hd__or3_2
XPHY_EDGE_ROW_56_Right_56 VGND VGND VPWR VPWR sky130_fd_sc_hd__decap_3
XFILLER_119_306 VGND VGND VPWR VPWR sky130_fd_sc_hd__fill_2
X_4681_ _4982_/B _5009_/A _6992_/Q _6993_/Q _6994_/Q VGND VGND VPWR VPWR _4960_/B
+ sky130_fd_sc_hd__o2111a_2
X_3701_ _3682_/A _3700_/X _4791_/A1 VGND VGND VPWR VPWR _3701_/X sky130_fd_sc_hd__a21o_2
X_6420_ _6644_/A VGND VGND VPWR VPWR _6420_/Y sky130_fd_sc_hd__inv_2
X_3632_ _3630_/A _3501_/X _3502_/X _3505_/B _5020_/A VGND VGND VPWR VPWR _3632_/X
+ sky130_fd_sc_hd__a311o_2
X_6351_ _6677_/A VGND VGND VPWR VPWR _6351_/Y sky130_fd_sc_hd__inv_2
X_5302_ _5302_/A0 _4771_/X _5315_/S VGND VGND VPWR VPWR _7179_/D sky130_fd_sc_hd__mux2_2
XFILLER_88_407 VGND VGND VPWR VPWR sky130_fd_sc_hd__decap_3
X_6282_ _6621_/A VGND VGND VPWR VPWR _6282_/Y sky130_fd_sc_hd__inv_2
X_3494_ _7183_/Q _3566_/A2 _4285_/B1 _7375_/Q VGND VGND VPWR VPWR _3494_/X sky130_fd_sc_hd__a22o_2
XFILLER_115_578 VGND VGND VPWR VPWR sky130_fd_sc_hd__decap_3
XFILLER_69_610 VGND VGND VPWR VPWR sky130_fd_sc_hd__decap_3
XTAP_TAPCELL_ROW_114_1681 VGND VPWR sky130_fd_sc_hd__tapvpwrvgnd_1
XPHY_EDGE_ROW_65_Right_65 VGND VGND VPWR VPWR sky130_fd_sc_hd__decap_3
XFILLER_102_228 VGND VGND VPWR VPWR sky130_fd_sc_hd__fill_1
XFILLER_102_239 VGND VGND VPWR VPWR sky130_fd_sc_hd__decap_3
XFILLER_69_632 VGND VGND VPWR VPWR sky130_fd_sc_hd__decap_3
XFILLER_110_250 VGND VGND VPWR VPWR sky130_fd_sc_hd__fill_2
XFILLER_68_153 VGND VGND VPWR VPWR sky130_fd_sc_hd__decap_3
XFILLER_69_665 VGND VGND VPWR VPWR sky130_fd_sc_hd__decap_3
XFILLER_69_676 VGND VGND VPWR VPWR sky130_fd_sc_hd__decap_3
XFILLER_96_451 VGND VGND VPWR VPWR sky130_fd_sc_hd__decap_3
X_4115_ _7268_/Q _4422_/A2 _4421_/A2 _7236_/Q _4114_/X VGND VGND VPWR VPWR _4117_/B
+ sky130_fd_sc_hd__a221o_2
XFILLER_56_315 VGND VGND VPWR VPWR sky130_fd_sc_hd__decap_3
XFILLER_68_186 VGND VGND VPWR VPWR sky130_fd_sc_hd__fill_1
XFILLER_68_197 VGND VGND VPWR VPWR sky130_fd_sc_hd__decap_3
X_5095_ _5095_/A0 _5094_/X _5159_/S VGND VGND VPWR VPWR _7256_/D sky130_fd_sc_hd__mux2_2
XPHY_EDGE_ROW_3_Left_123 VGND VGND VPWR VPWR sky130_fd_sc_hd__decap_3
XFILLER_56_359 VGND VGND VPWR VPWR sky130_fd_sc_hd__fill_2
XFILLER_83_156 VGND VGND VPWR VPWR sky130_fd_sc_hd__fill_2
XFILLER_84_657 VGND VGND VPWR VPWR sky130_fd_sc_hd__decap_3
X_4046_ _7373_/Q _4416_/A2 _4436_/B1 _7181_/Q VGND VGND VPWR VPWR _4046_/X sky130_fd_sc_hd__a22o_2
XFILLER_52_510 VGND VGND VPWR VPWR sky130_fd_sc_hd__fill_1
XFILLER_83_178 VGND VGND VPWR VPWR sky130_fd_sc_hd__decap_3
XFILLER_24_212 VGND VGND VPWR VPWR sky130_fd_sc_hd__decap_3
XFILLER_52_521 VGND VGND VPWR VPWR sky130_fd_sc_hd__decap_3
XFILLER_92_690 VGND VGND VPWR VPWR sky130_fd_sc_hd__decap_3
XTAP_TAPCELL_ROW_65_1068 VGND VPWR sky130_fd_sc_hd__tapvpwrvgnd_1
XPHY_EDGE_ROW_74_Right_74 VGND VGND VPWR VPWR sky130_fd_sc_hd__decap_3
X_4948_ _4948_/A _4948_/B VGND VGND VPWR VPWR _4948_/Y sky130_fd_sc_hd__nor2_2
X_4879_ _4879_/A0 _4878_/X _4979_/S VGND VGND VPWR VPWR _7269_/D sky130_fd_sc_hd__mux2_2
XFILLER_20_473 VGND VGND VPWR VPWR sky130_fd_sc_hd__decap_3
X_6618_ _6650_/A VGND VGND VPWR VPWR _6618_/Y sky130_fd_sc_hd__inv_2
XPHY_EDGE_ROW_49_Left_169 VGND VGND VPWR VPWR sky130_fd_sc_hd__decap_3
XFILLER_116_6 VGND VGND VPWR VPWR sky130_fd_sc_hd__decap_3
XFILLER_4_617 VGND VGND VPWR VPWR sky130_fd_sc_hd__decap_3
XFILLER_106_512 VGND VGND VPWR VPWR sky130_fd_sc_hd__decap_3
X_6549_ _6550_/A VGND VGND VPWR VPWR _6549_/Y sky130_fd_sc_hd__inv_2
XPHY_EDGE_ROW_83_Right_83 VGND VGND VPWR VPWR sky130_fd_sc_hd__decap_3
XFILLER_106_589 VGND VGND VPWR VPWR sky130_fd_sc_hd__decap_3
XFILLER_47_304 VGND VGND VPWR VPWR sky130_fd_sc_hd__decap_3
XFILLER_59_131 VGND VGND VPWR VPWR sky130_fd_sc_hd__decap_3
XFILLER_59_164 VGND VGND VPWR VPWR sky130_fd_sc_hd__decap_3
XFILLER_75_613 VGND VGND VPWR VPWR sky130_fd_sc_hd__decap_3
XFILLER_87_473 VGND VGND VPWR VPWR sky130_fd_sc_hd__decap_3
XPHY_EDGE_ROW_58_Left_178 VGND VGND VPWR VPWR sky130_fd_sc_hd__decap_3
XFILLER_47_337 VGND VGND VPWR VPWR sky130_fd_sc_hd__decap_3
XFILLER_74_112 VGND VGND VPWR VPWR sky130_fd_sc_hd__decap_3
XFILLER_75_635 VGND VGND VPWR VPWR sky130_fd_sc_hd__decap_3
XFILLER_114_62 VGND VGND VPWR VPWR sky130_fd_sc_hd__decap_3
XFILLER_74_156 VGND VGND VPWR VPWR sky130_fd_sc_hd__decap_3
XFILLER_75_668 VGND VGND VPWR VPWR sky130_fd_sc_hd__decap_3
XFILLER_75_679 VGND VGND VPWR VPWR sky130_fd_sc_hd__decap_3
XFILLER_16_713 VGND VGND VPWR VPWR sky130_fd_sc_hd__fill_1
XFILLER_28_562 VGND VGND VPWR VPWR sky130_fd_sc_hd__fill_2
XFILLER_62_307 VGND VGND VPWR VPWR sky130_fd_sc_hd__fill_1
XFILLER_74_189 VGND VGND VPWR VPWR sky130_fd_sc_hd__decap_3
XFILLER_74_77 VGND VGND VPWR VPWR sky130_fd_sc_hd__decap_3
XFILLER_15_234 VGND VGND VPWR VPWR sky130_fd_sc_hd__decap_3
XFILLER_28_595 VGND VGND VPWR VPWR sky130_fd_sc_hd__decap_3
XFILLER_55_381 VGND VGND VPWR VPWR sky130_fd_sc_hd__decap_3
XFILLER_74_88 VGND VGND VPWR VPWR sky130_fd_sc_hd__decap_3
XPHY_EDGE_ROW_92_Right_92 VGND VGND VPWR VPWR sky130_fd_sc_hd__decap_3
XFILLER_43_554 VGND VGND VPWR VPWR sky130_fd_sc_hd__decap_3
XFILLER_30_226 VGND VGND VPWR VPWR sky130_fd_sc_hd__decap_3
XTAP_TAPCELL_ROW_13_424 VGND VPWR sky130_fd_sc_hd__tapvpwrvgnd_1
XTAP_TAPCELL_ROW_41_766 VGND VPWR sky130_fd_sc_hd__tapvpwrvgnd_1
XPHY_EDGE_ROW_67_Left_187 VGND VGND VPWR VPWR sky130_fd_sc_hd__decap_3
XFILLER_11_473 VGND VGND VPWR VPWR sky130_fd_sc_hd__decap_3
XFILLER_109_350 VGND VGND VPWR VPWR sky130_fd_sc_hd__fill_1
XFILLER_116_309 VGND VGND VPWR VPWR sky130_fd_sc_hd__fill_1
XFILLER_7_466 VGND VGND VPWR VPWR sky130_fd_sc_hd__decap_3
XFILLER_109_383 VGND VGND VPWR VPWR sky130_fd_sc_hd__decap_3
XFILLER_99_74 VGND VGND VPWR VPWR sky130_fd_sc_hd__decap_3
XFILLER_3_650 VGND VGND VPWR VPWR sky130_fd_sc_hd__decap_3
XFILLER_97_204 VGND VGND VPWR VPWR sky130_fd_sc_hd__decap_3
XFILLER_3_694 VGND VGND VPWR VPWR sky130_fd_sc_hd__decap_3
XFILLER_97_259 VGND VGND VPWR VPWR sky130_fd_sc_hd__decap_3
XPHY_EDGE_ROW_76_Left_196 VGND VGND VPWR VPWR sky130_fd_sc_hd__decap_3
XFILLER_38_304 VGND VGND VPWR VPWR sky130_fd_sc_hd__decap_3
XFILLER_78_451 VGND VGND VPWR VPWR sky130_fd_sc_hd__decap_3
XFILLER_66_635 VGND VGND VPWR VPWR sky130_fd_sc_hd__decap_3
XFILLER_78_473 VGND VGND VPWR VPWR sky130_fd_sc_hd__decap_3
XFILLER_38_348 VGND VGND VPWR VPWR sky130_fd_sc_hd__fill_2
XFILLER_65_134 VGND VGND VPWR VPWR sky130_fd_sc_hd__fill_1
XFILLER_66_657 VGND VGND VPWR VPWR sky130_fd_sc_hd__decap_3
XFILLER_81_605 VGND VGND VPWR VPWR sky130_fd_sc_hd__decap_3
XFILLER_93_443 VGND VGND VPWR VPWR sky130_fd_sc_hd__decap_3
XTAP_TAPCELL_ROW_49_866 VGND VPWR sky130_fd_sc_hd__tapvpwrvgnd_1
XFILLER_65_167 VGND VGND VPWR VPWR sky130_fd_sc_hd__fill_1
XFILLER_80_115 VGND VGND VPWR VPWR sky130_fd_sc_hd__decap_3
XFILLER_81_638 VGND VGND VPWR VPWR sky130_fd_sc_hd__decap_3
XFILLER_93_476 VGND VGND VPWR VPWR sky130_fd_sc_hd__decap_3
XFILLER_0_85 VGND VGND VPWR VPWR sky130_fd_sc_hd__decap_3
XFILLER_19_595 VGND VGND VPWR VPWR sky130_fd_sc_hd__decap_3
XFILLER_46_392 VGND VGND VPWR VPWR sky130_fd_sc_hd__decap_3
XFILLER_74_690 VGND VGND VPWR VPWR sky130_fd_sc_hd__decap_3
XFILLER_61_340 VGND VGND VPWR VPWR sky130_fd_sc_hd__decap_3
XFILLER_21_237 VGND VGND VPWR VPWR sky130_fd_sc_hd__fill_1
XFILLER_34_587 VGND VGND VPWR VPWR sky130_fd_sc_hd__fill_1
XFILLER_34_598 VGND VGND VPWR VPWR sky130_fd_sc_hd__decap_3
X_4802_ _7002_/Q _4690_/B _4834_/A VGND VGND VPWR VPWR _4802_/X sky130_fd_sc_hd__o21a_2
XPHY_EDGE_ROW_100_Right_100 VGND VGND VPWR VPWR sky130_fd_sc_hd__decap_3
XFILLER_21_248 VGND VGND VPWR VPWR sky130_fd_sc_hd__decap_3
XFILLER_9_72 VGND VGND VPWR VPWR sky130_fd_sc_hd__fill_2
XFILLER_119_18 VGND VGND VPWR VPWR sky130_fd_sc_hd__decap_3
XFILLER_119_147 VGND VGND VPWR VPWR sky130_fd_sc_hd__decap_3
XFILLER_119_169 VGND VGND VPWR VPWR sky130_fd_sc_hd__decap_3
XFILLER_119_29 VGND VGND VPWR VPWR sky130_fd_sc_hd__decap_3
X_6403_ _6627_/A VGND VGND VPWR VPWR _6403_/Y sky130_fd_sc_hd__inv_2
X_4664_ _4857_/A _4664_/B _5665_/A VGND VGND VPWR VPWR _4664_/X sky130_fd_sc_hd__or3b_4
X_7383_ _7387_/CLK _7383_/D _6663_/Y VGND VGND VPWR VPWR _7383_/Q sky130_fd_sc_hd__dfrtp_2
Xhold901 _6754_/Q VGND VGND VPWR VPWR _6754_/D sky130_fd_sc_hd__dlygate4sd3_1
Xhold912 _6769_/Q VGND VGND VPWR VPWR _6769_/D sky130_fd_sc_hd__dlygate4sd3_1
X_4595_ _4595_/A _4595_/B VGND VGND VPWR VPWR _7283_/D sky130_fd_sc_hd__and2_2
X_3615_ _3508_/A _3547_/Y _3427_/B VGND VGND VPWR VPWR _3616_/B sky130_fd_sc_hd__o21ai_2
XTAP_TAPCELL_ROW_116_1710 VGND VPWR sky130_fd_sc_hd__tapvpwrvgnd_1
Xhold923 _6740_/Q VGND VGND VPWR VPWR _6740_/D sky130_fd_sc_hd__dlygate4sd3_1
Xhold934 _6923_/Q VGND VGND VPWR VPWR _6923_/D sky130_fd_sc_hd__dlygate4sd3_1
Xhold945 _7066_/Q VGND VGND VPWR VPWR _7066_/D sky130_fd_sc_hd__dlygate4sd3_1
X_6334_ _6483_/A VGND VGND VPWR VPWR _6334_/Y sky130_fd_sc_hd__inv_2
X_3546_ _3630_/A _3630_/B _3635_/A _3636_/A VGND VGND VPWR VPWR _3547_/B sky130_fd_sc_hd__a211o_2
XFILLER_103_526 VGND VGND VPWR VPWR sky130_fd_sc_hd__fill_2
XFILLER_1_609 VGND VGND VPWR VPWR sky130_fd_sc_hd__decap_3
XFILLER_88_215 VGND VGND VPWR VPWR sky130_fd_sc_hd__decap_3
Xhold956 _7074_/Q VGND VGND VPWR VPWR _7074_/D sky130_fd_sc_hd__dlygate4sd3_1
Xhold967 _7091_/Q VGND VGND VPWR VPWR _7091_/D sky130_fd_sc_hd__dlygate4sd3_1
Xhold978 _7060_/Q VGND VGND VPWR VPWR _7060_/D sky130_fd_sc_hd__dlygate4sd3_1
Xmax_cap675 _3562_/A VGND VGND VPWR VPWR _4285_/A2 sky130_fd_sc_hd__buf_2
Xmax_cap664 _4447_/A VGND VGND VPWR VPWR _4795_/A sky130_fd_sc_hd__clkbuf_4
Xhold989 _7079_/Q VGND VGND VPWR VPWR _7079_/D sky130_fd_sc_hd__dlygate4sd3_1
X_6265_ _6671_/A VGND VGND VPWR VPWR _6265_/Y sky130_fd_sc_hd__inv_2
XFILLER_88_248 VGND VGND VPWR VPWR sky130_fd_sc_hd__decap_3
X_3477_ _7184_/Q _4471_/S _4261_/A2 _7376_/Q VGND VGND VPWR VPWR _3477_/X sky130_fd_sc_hd__a22o_2
XFILLER_69_440 VGND VGND VPWR VPWR sky130_fd_sc_hd__decap_3
XFILLER_88_259 VGND VGND VPWR VPWR sky130_fd_sc_hd__decap_3
XFILLER_111_570 VGND VGND VPWR VPWR sky130_fd_sc_hd__decap_3
XFILLER_29_304 VGND VGND VPWR VPWR sky130_fd_sc_hd__decap_3
XFILLER_29_337 VGND VGND VPWR VPWR sky130_fd_sc_hd__decap_3
XFILLER_56_112 VGND VGND VPWR VPWR sky130_fd_sc_hd__decap_3
XFILLER_57_635 VGND VGND VPWR VPWR sky130_fd_sc_hd__decap_3
XFILLER_69_484 VGND VGND VPWR VPWR sky130_fd_sc_hd__decap_3
XFILLER_84_421 VGND VGND VPWR VPWR sky130_fd_sc_hd__decap_3
X_5147_ _5145_/A _3541_/X _5146_/Y VGND VGND VPWR VPWR _5147_/X sky130_fd_sc_hd__a21o_2
XFILLER_56_156 VGND VGND VPWR VPWR sky130_fd_sc_hd__fill_2
XFILLER_57_668 VGND VGND VPWR VPWR sky130_fd_sc_hd__decap_3
XFILLER_57_679 VGND VGND VPWR VPWR sky130_fd_sc_hd__decap_3
XFILLER_84_465 VGND VGND VPWR VPWR sky130_fd_sc_hd__decap_3
X_5078_ _5581_/S _5069_/X _5077_/X _4467_/B _4606_/A VGND VGND VPWR VPWR _5078_/X
+ sky130_fd_sc_hd__a221o_2
XFILLER_56_178 VGND VGND VPWR VPWR sky130_fd_sc_hd__decap_3
XFILLER_72_616 VGND VGND VPWR VPWR sky130_fd_sc_hd__decap_3
XFILLER_71_159 VGND VGND VPWR VPWR sky130_fd_sc_hd__decap_3
XFILLER_80_660 VGND VGND VPWR VPWR sky130_fd_sc_hd__decap_3
XFILLER_25_598 VGND VGND VPWR VPWR sky130_fd_sc_hd__decap_3
XFILLER_40_513 VGND VGND VPWR VPWR sky130_fd_sc_hd__fill_2
XFILLER_80_693 VGND VGND VPWR VPWR sky130_fd_sc_hd__decap_3
XFILLER_9_709 VGND VGND VPWR VPWR sky130_fd_sc_hd__decap_3
XFILLER_100_53 VGND VGND VPWR VPWR sky130_fd_sc_hd__decap_3
XFILLER_40_557 VGND VGND VPWR VPWR sky130_fd_sc_hd__decap_3
XFILLER_4_403 VGND VGND VPWR VPWR sky130_fd_sc_hd__decap_3
XTAP_TAPCELL_ROW_78_1237 VGND VPWR sky130_fd_sc_hd__tapvpwrvgnd_1
XFILLER_109_51 VGND VGND VPWR VPWR sky130_fd_sc_hd__decap_3
XFILLER_118_180 VGND VGND VPWR VPWR sky130_fd_sc_hd__decap_3
XFILLER_69_11 VGND VGND VPWR VPWR sky130_fd_sc_hd__fill_1
XFILLER_69_66 VGND VGND VPWR VPWR sky130_fd_sc_hd__fill_2
XFILLER_0_620 VGND VGND VPWR VPWR sky130_fd_sc_hd__decap_3
XFILLER_106_386 VGND VGND VPWR VPWR sky130_fd_sc_hd__decap_3
XFILLER_79_237 VGND VGND VPWR VPWR sky130_fd_sc_hd__decap_3
XFILLER_0_642 VGND VGND VPWR VPWR sky130_fd_sc_hd__fill_2
XFILLER_48_602 VGND VGND VPWR VPWR sky130_fd_sc_hd__decap_3
XFILLER_0_697 VGND VGND VPWR VPWR sky130_fd_sc_hd__decap_3
XFILLER_102_570 VGND VGND VPWR VPWR sky130_fd_sc_hd__decap_3
XFILLER_48_635 VGND VGND VPWR VPWR sky130_fd_sc_hd__decap_3
XFILLER_87_270 VGND VGND VPWR VPWR sky130_fd_sc_hd__fill_1
XFILLER_87_281 VGND VGND VPWR VPWR sky130_fd_sc_hd__decap_3
XFILLER_48_657 VGND VGND VPWR VPWR sky130_fd_sc_hd__decap_3
XFILLER_47_156 VGND VGND VPWR VPWR sky130_fd_sc_hd__decap_3
XFILLER_63_638 VGND VGND VPWR VPWR sky130_fd_sc_hd__decap_3
XFILLER_85_87 VGND VGND VPWR VPWR sky130_fd_sc_hd__decap_3
XTAP_TAPCELL_ROW_89_1366 VGND VPWR sky130_fd_sc_hd__tapvpwrvgnd_1
XFILLER_16_510 VGND VGND VPWR VPWR sky130_fd_sc_hd__fill_2
XFILLER_16_521 VGND VGND VPWR VPWR sky130_fd_sc_hd__decap_3
XFILLER_28_392 VGND VGND VPWR VPWR sky130_fd_sc_hd__decap_3
XFILLER_56_690 VGND VGND VPWR VPWR sky130_fd_sc_hd__decap_3
XFILLER_62_126 VGND VGND VPWR VPWR sky130_fd_sc_hd__decap_3
XFILLER_90_424 VGND VGND VPWR VPWR sky130_fd_sc_hd__decap_3
XTAP_TAPCELL_ROW_46_836 VGND VPWR sky130_fd_sc_hd__tapvpwrvgnd_1
XFILLER_43_340 VGND VGND VPWR VPWR sky130_fd_sc_hd__fill_1
XFILLER_71_671 VGND VGND VPWR VPWR sky130_fd_sc_hd__fill_1
XFILLER_16_587 VGND VGND VPWR VPWR sky130_fd_sc_hd__fill_1
XFILLER_16_598 VGND VGND VPWR VPWR sky130_fd_sc_hd__decap_3
XFILLER_71_682 VGND VGND VPWR VPWR sky130_fd_sc_hd__decap_3
XTAP_TAPCELL_ROW_26_582 VGND VPWR sky130_fd_sc_hd__tapvpwrvgnd_1
XFILLER_31_568 VGND VGND VPWR VPWR sky130_fd_sc_hd__decap_3
XFILLER_34_91 VGND VGND VPWR VPWR sky130_fd_sc_hd__fill_2
XTAP_TAPCELL_ROW_100_1511 VGND VPWR sky130_fd_sc_hd__tapvpwrvgnd_1
XFILLER_11_270 VGND VGND VPWR VPWR sky130_fd_sc_hd__decap_3
XFILLER_11_281 VGND VGND VPWR VPWR sky130_fd_sc_hd__fill_2
XFILLER_11_292 VGND VGND VPWR VPWR sky130_fd_sc_hd__decap_3
XFILLER_79_6 VGND VGND VPWR VPWR sky130_fd_sc_hd__decap_3
XFILLER_116_106 VGND VGND VPWR VPWR sky130_fd_sc_hd__decap_3
XFILLER_117_629 VGND VGND VPWR VPWR sky130_fd_sc_hd__decap_3
XFILLER_7_263 VGND VGND VPWR VPWR sky130_fd_sc_hd__decap_3
XFILLER_116_139 VGND VGND VPWR VPWR sky130_fd_sc_hd__fill_1
XFILLER_7_296 VGND VGND VPWR VPWR sky130_fd_sc_hd__decap_3
X_4380_ _4380_/A _4380_/B VGND VGND VPWR VPWR _4381_/B sky130_fd_sc_hd__or2_2
X_3400_ _3449_/B VGND VGND VPWR VPWR _3421_/B sky130_fd_sc_hd__inv_2
XFILLER_98_502 VGND VGND VPWR VPWR sky130_fd_sc_hd__decap_3
X_3331_ _3365_/A _5667_/A _3324_/A VGND VGND VPWR VPWR _3528_/A sky130_fd_sc_hd__or3b_2
XPHY_EDGE_ROW_84_Left_204 VGND VGND VPWR VPWR sky130_fd_sc_hd__decap_3
XFILLER_112_312 VGND VGND VPWR VPWR sky130_fd_sc_hd__decap_3
XFILLER_98_557 VGND VGND VPWR VPWR sky130_fd_sc_hd__decap_3
XFILLER_85_207 VGND VGND VPWR VPWR sky130_fd_sc_hd__decap_3
XFILLER_98_579 VGND VGND VPWR VPWR sky130_fd_sc_hd__decap_3
XTAP_TAPCELL_ROW_111_1651 VGND VPWR sky130_fd_sc_hd__tapvpwrvgnd_1
XTAP_TAPCELL_ROW_111_1640 VGND VPWR sky130_fd_sc_hd__tapvpwrvgnd_1
XFILLER_39_613 VGND VGND VPWR VPWR sky130_fd_sc_hd__decap_3
XFILLER_39_635 VGND VGND VPWR VPWR sky130_fd_sc_hd__decap_3
XFILLER_78_281 VGND VGND VPWR VPWR sky130_fd_sc_hd__fill_1
X_5001_ _5001_/A _5001_/B VGND VGND VPWR VPWR _6991_/D sky130_fd_sc_hd__nor2_2
XFILLER_39_668 VGND VGND VPWR VPWR sky130_fd_sc_hd__decap_3
XFILLER_93_240 VGND VGND VPWR VPWR sky130_fd_sc_hd__fill_2
XFILLER_26_329 VGND VGND VPWR VPWR sky130_fd_sc_hd__decap_3
XFILLER_38_167 VGND VGND VPWR VPWR sky130_fd_sc_hd__decap_3
XFILLER_39_679 VGND VGND VPWR VPWR sky130_fd_sc_hd__decap_3
XFILLER_53_104 VGND VGND VPWR VPWR sky130_fd_sc_hd__decap_3
XFILLER_54_627 VGND VGND VPWR VPWR sky130_fd_sc_hd__decap_3
XFILLER_81_424 VGND VGND VPWR VPWR sky130_fd_sc_hd__decap_3
XFILLER_81_446 VGND VGND VPWR VPWR sky130_fd_sc_hd__fill_2
XFILLER_93_284 VGND VGND VPWR VPWR sky130_fd_sc_hd__decap_3
X_6952_ _6983_/CLK _6952_/D VGND VGND VPWR VPWR _6952_/Q sky130_fd_sc_hd__dfxtp_2
XPHY_EDGE_ROW_93_Left_213 VGND VGND VPWR VPWR sky130_fd_sc_hd__decap_3
XFILLER_34_351 VGND VGND VPWR VPWR sky130_fd_sc_hd__decap_3
XFILLER_62_660 VGND VGND VPWR VPWR sky130_fd_sc_hd__decap_3
X_6883_ _6943_/CLK _6883_/D VGND VGND VPWR VPWR _6883_/Q sky130_fd_sc_hd__dfxtp_2
XFILLER_62_693 VGND VGND VPWR VPWR sky130_fd_sc_hd__decap_3
XTAP_TAPCELL_ROW_62_1027 VGND VPWR sky130_fd_sc_hd__tapvpwrvgnd_1
XTAP_TAPCELL_ROW_62_1038 VGND VPWR sky130_fd_sc_hd__tapvpwrvgnd_1
XFILLER_22_579 VGND VGND VPWR VPWR sky130_fd_sc_hd__decap_3
XFILLER_108_607 VGND VGND VPWR VPWR sky130_fd_sc_hd__decap_3
X_4716_ _4910_/A _4664_/X _4695_/X _7008_/D _5666_/A VGND VGND VPWR VPWR _4716_/X
+ sky130_fd_sc_hd__a32o_2
X_4647_ _4813_/A _4827_/A _4795_/A _4787_/A VGND VGND VPWR VPWR _4647_/X sky130_fd_sc_hd__and4_2
XFILLER_116_640 VGND VGND VPWR VPWR sky130_fd_sc_hd__decap_3
X_7366_ _7400_/CLK _7366_/D _6646_/Y VGND VGND VPWR VPWR _7366_/Q sky130_fd_sc_hd__dfrtp_2
Xhold720 _6972_/Q VGND VGND VPWR VPWR _6972_/D sky130_fd_sc_hd__dlygate4sd3_1
XFILLER_116_651 VGND VGND VPWR VPWR sky130_fd_sc_hd__decap_3
XFILLER_116_684 VGND VGND VPWR VPWR sky130_fd_sc_hd__decap_3
XFILLER_1_406 VGND VGND VPWR VPWR sky130_fd_sc_hd__fill_1
Xhold731 _6835_/Q VGND VGND VPWR VPWR _6835_/D sky130_fd_sc_hd__dlygate4sd3_1
Xhold742 _6732_/Q VGND VGND VPWR VPWR _6732_/D sky130_fd_sc_hd__dlygate4sd3_1
Xhold753 _6725_/Q VGND VGND VPWR VPWR _6725_/D sky130_fd_sc_hd__dlygate4sd3_1
Xhold764 _6928_/Q VGND VGND VPWR VPWR _6928_/D sky130_fd_sc_hd__dlygate4sd3_1
X_6317_ _6636_/A VGND VGND VPWR VPWR _6317_/Y sky130_fd_sc_hd__inv_2
XFILLER_115_161 VGND VGND VPWR VPWR sky130_fd_sc_hd__decap_3
XFILLER_1_428 VGND VGND VPWR VPWR sky130_fd_sc_hd__fill_1
XFILLER_89_546 VGND VGND VPWR VPWR sky130_fd_sc_hd__decap_3
X_7297_ _7333_/CLK _7297_/D _6577_/Y VGND VGND VPWR VPWR _7297_/Q sky130_fd_sc_hd__dfrtp_2
Xhold775 _6877_/Q VGND VGND VPWR VPWR _6877_/D sky130_fd_sc_hd__dlygate4sd3_1
Xhold786 _6762_/Q VGND VGND VPWR VPWR _6762_/D sky130_fd_sc_hd__dlygate4sd3_1
Xhold797 _6813_/Q VGND VGND VPWR VPWR _6813_/D sky130_fd_sc_hd__dlygate4sd3_1
XFILLER_103_345 VGND VGND VPWR VPWR sky130_fd_sc_hd__decap_3
XFILLER_76_207 VGND VGND VPWR VPWR sky130_fd_sc_hd__decap_3
XTAP_TAPCELL_ROW_73_1167 VGND VPWR sky130_fd_sc_hd__tapvpwrvgnd_1
XFILLER_29_145 VGND VGND VPWR VPWR sky130_fd_sc_hd__fill_1
XFILLER_69_281 VGND VGND VPWR VPWR sky130_fd_sc_hd__decap_3
XFILLER_17_307 VGND VGND VPWR VPWR sky130_fd_sc_hd__decap_3
XFILLER_29_178 VGND VGND VPWR VPWR sky130_fd_sc_hd__decap_3
XFILLER_45_605 VGND VGND VPWR VPWR sky130_fd_sc_hd__decap_3
XFILLER_84_251 VGND VGND VPWR VPWR sky130_fd_sc_hd__fill_1
XFILLER_17_329 VGND VGND VPWR VPWR sky130_fd_sc_hd__fill_1
XFILLER_38_690 VGND VGND VPWR VPWR sky130_fd_sc_hd__decap_3
XFILLER_44_137 VGND VGND VPWR VPWR sky130_fd_sc_hd__decap_3
XFILLER_45_638 VGND VGND VPWR VPWR sky130_fd_sc_hd__decap_3
XFILLER_84_284 VGND VGND VPWR VPWR sky130_fd_sc_hd__decap_3
XFILLER_111_30 VGND VGND VPWR VPWR sky130_fd_sc_hd__decap_3
XFILLER_25_340 VGND VGND VPWR VPWR sky130_fd_sc_hd__decap_3
XFILLER_60_619 VGND VGND VPWR VPWR sky130_fd_sc_hd__decap_3
XFILLER_111_63 VGND VGND VPWR VPWR sky130_fd_sc_hd__decap_3
XFILLER_53_671 VGND VGND VPWR VPWR sky130_fd_sc_hd__fill_1
XFILLER_53_682 VGND VGND VPWR VPWR sky130_fd_sc_hd__decap_3
XFILLER_71_12 VGND VGND VPWR VPWR sky130_fd_sc_hd__fill_1
XTAP_TAPCELL_ROW_23_541 VGND VPWR sky130_fd_sc_hd__tapvpwrvgnd_1
XFILLER_13_579 VGND VGND VPWR VPWR sky130_fd_sc_hd__decap_3
XFILLER_40_354 VGND VGND VPWR VPWR sky130_fd_sc_hd__fill_1
XFILLER_40_376 VGND VGND VPWR VPWR sky130_fd_sc_hd__decap_3
XTAP_TAPCELL_ROW_51_894 VGND VPWR sky130_fd_sc_hd__tapvpwrvgnd_1
XFILLER_5_712 VGND VGND VPWR VPWR sky130_fd_sc_hd__fill_2
XFILLER_4_222 VGND VGND VPWR VPWR sky130_fd_sc_hd__fill_2
XFILLER_107_662 VGND VGND VPWR VPWR sky130_fd_sc_hd__decap_3
XFILLER_107_673 VGND VGND VPWR VPWR sky130_fd_sc_hd__decap_3
XFILLER_113_109 VGND VGND VPWR VPWR sky130_fd_sc_hd__decap_3
XFILLER_4_244 VGND VGND VPWR VPWR sky130_fd_sc_hd__fill_1
XFILLER_106_172 VGND VGND VPWR VPWR sky130_fd_sc_hd__decap_3
XFILLER_20_82 VGND VGND VPWR VPWR sky130_fd_sc_hd__fill_2
XFILLER_4_277 VGND VGND VPWR VPWR sky130_fd_sc_hd__decap_3
XFILLER_4_288 VGND VGND VPWR VPWR sky130_fd_sc_hd__decap_3
XFILLER_95_505 VGND VGND VPWR VPWR sky130_fd_sc_hd__fill_1
XFILLER_0_461 VGND VGND VPWR VPWR sky130_fd_sc_hd__decap_3
XFILLER_67_207 VGND VGND VPWR VPWR sky130_fd_sc_hd__decap_3
XFILLER_0_483 VGND VGND VPWR VPWR sky130_fd_sc_hd__decap_3
XFILLER_35_104 VGND VGND VPWR VPWR sky130_fd_sc_hd__decap_3
XFILLER_36_616 VGND VGND VPWR VPWR sky130_fd_sc_hd__decap_3
XFILLER_63_413 VGND VGND VPWR VPWR sky130_fd_sc_hd__decap_3
XFILLER_75_240 VGND VGND VPWR VPWR sky130_fd_sc_hd__decap_3
XFILLER_75_262 VGND VGND VPWR VPWR sky130_fd_sc_hd__decap_3
XFILLER_91_700 VGND VGND VPWR VPWR sky130_fd_sc_hd__decap_3
XFILLER_90_221 VGND VGND VPWR VPWR sky130_fd_sc_hd__decap_3
Xplace413 _5080_/S VGND VGND VPWR VPWR _4914_/S sky130_fd_sc_hd__buf_2
Xplace402 _4337_/B VGND VGND VPWR VPWR _4272_/B sky130_fd_sc_hd__buf_2
XTAP_TAPCELL_ROW_59_994 VGND VPWR sky130_fd_sc_hd__tapvpwrvgnd_1
XFILLER_35_148 VGND VGND VPWR VPWR sky130_fd_sc_hd__decap_3
XFILLER_44_660 VGND VGND VPWR VPWR sky130_fd_sc_hd__decap_3
XFILLER_90_243 VGND VGND VPWR VPWR sky130_fd_sc_hd__decap_3
Xplace446 _3326_/A VGND VGND VPWR VPWR _5648_/A sky130_fd_sc_hd__buf_2
Xplace435 _4263_/A2 VGND VGND VPWR VPWR _4428_/B1 sky130_fd_sc_hd__buf_2
Xplace424 _3556_/A VGND VGND VPWR VPWR _4347_/C1 sky130_fd_sc_hd__buf_2
XFILLER_16_373 VGND VGND VPWR VPWR sky130_fd_sc_hd__decap_3
XFILLER_44_693 VGND VGND VPWR VPWR sky130_fd_sc_hd__decap_3
XFILLER_50_107 VGND VGND VPWR VPWR sky130_fd_sc_hd__decap_3
XFILLER_90_298 VGND VGND VPWR VPWR sky130_fd_sc_hd__decap_3
Xplace479 _3996_/S VGND VGND VPWR VPWR _3975_/S sky130_fd_sc_hd__buf_2
Xplace468 _4346_/B1 VGND VGND VPWR VPWR _4338_/B1 sky130_fd_sc_hd__buf_2
Xplace457 _4532_/S VGND VGND VPWR VPWR _4300_/B sky130_fd_sc_hd__buf_2
XFILLER_31_332 VGND VGND VPWR VPWR sky130_fd_sc_hd__decap_3
XFILLER_43_181 VGND VGND VPWR VPWR sky130_fd_sc_hd__decap_3
X_3880_ _3714_/X _3877_/X _3879_/X _3735_/X VGND VGND VPWR VPWR _3880_/X sky130_fd_sc_hd__a22o_2
XFILLER_31_354 VGND VGND VPWR VPWR sky130_fd_sc_hd__decap_3
XFILLER_31_387 VGND VGND VPWR VPWR sky130_fd_sc_hd__decap_3
XFILLER_77_3 VGND VGND VPWR VPWR sky130_fd_sc_hd__decap_3
XFILLER_8_572 VGND VGND VPWR VPWR sky130_fd_sc_hd__decap_3
X_4501_ _4501_/A0 _7297_/Q _4517_/S VGND VGND VPWR VPWR _7329_/D sky130_fd_sc_hd__mux2_2
XFILLER_117_437 VGND VGND VPWR VPWR sky130_fd_sc_hd__decap_3
X_7220_ _7313_/CLK _7220_/D _6500_/Y VGND VGND VPWR VPWR _7220_/Q sky130_fd_sc_hd__dfrtp_2
X_4432_ _7079_/Q _4102_/B _4432_/B1 _4431_/X VGND VGND VPWR VPWR _4440_/A sky130_fd_sc_hd__o211ai_2
XFILLER_113_632 VGND VGND VPWR VPWR sky130_fd_sc_hd__decap_3
XFILLER_98_321 VGND VGND VPWR VPWR sky130_fd_sc_hd__decap_3
X_7151_ _7349_/CLK _7151_/D _6431_/Y VGND VGND VPWR VPWR _7151_/Q sky130_fd_sc_hd__dfrtp_2
X_4363_ _4619_/B VGND VGND VPWR VPWR _4369_/A sky130_fd_sc_hd__inv_2
XFILLER_113_665 VGND VGND VPWR VPWR sky130_fd_sc_hd__decap_3
XFILLER_113_676 VGND VGND VPWR VPWR sky130_fd_sc_hd__decap_3
XFILLER_98_365 VGND VGND VPWR VPWR sky130_fd_sc_hd__decap_3
X_7082_ _7402_/CLK _7082_/D _6362_/Y VGND VGND VPWR VPWR _7082_/Q sky130_fd_sc_hd__dfrtp_2
X_4294_ _4612_/A _4612_/B VGND VGND VPWR VPWR _5113_/A sky130_fd_sc_hd__xor2_2
X_3314_ _4467_/A _4467_/B VGND VGND VPWR VPWR _5647_/A sky130_fd_sc_hd__or2_2
XFILLER_112_186 VGND VGND VPWR VPWR sky130_fd_sc_hd__decap_3
XFILLER_58_218 VGND VGND VPWR VPWR sky130_fd_sc_hd__decap_3
XFILLER_86_527 VGND VGND VPWR VPWR sky130_fd_sc_hd__fill_1
XFILLER_98_376 VGND VGND VPWR VPWR sky130_fd_sc_hd__decap_3
XFILLER_112_197 VGND VGND VPWR VPWR sky130_fd_sc_hd__decap_3
XFILLER_39_421 VGND VGND VPWR VPWR sky130_fd_sc_hd__decap_3
XFILLER_54_402 VGND VGND VPWR VPWR sky130_fd_sc_hd__decap_3
XFILLER_66_251 VGND VGND VPWR VPWR sky130_fd_sc_hd__fill_1
XFILLER_94_571 VGND VGND VPWR VPWR sky130_fd_sc_hd__decap_3
XFILLER_26_126 VGND VGND VPWR VPWR sky130_fd_sc_hd__decap_3
XFILLER_27_638 VGND VGND VPWR VPWR sky130_fd_sc_hd__decap_3
XFILLER_54_424 VGND VGND VPWR VPWR sky130_fd_sc_hd__decap_3
XFILLER_54_457 VGND VGND VPWR VPWR sky130_fd_sc_hd__decap_3
X_6935_ _6943_/CLK _6935_/D VGND VGND VPWR VPWR _6935_/Q sky130_fd_sc_hd__dfxtp_2
XTAP_TAPCELL_ROW_1_269 VGND VPWR sky130_fd_sc_hd__tapvpwrvgnd_1
XFILLER_35_671 VGND VGND VPWR VPWR sky130_fd_sc_hd__fill_1
XFILLER_35_682 VGND VGND VPWR VPWR sky130_fd_sc_hd__decap_3
XFILLER_41_107 VGND VGND VPWR VPWR sky130_fd_sc_hd__decap_3
XFILLER_22_321 VGND VGND VPWR VPWR sky130_fd_sc_hd__decap_3
XFILLER_34_181 VGND VGND VPWR VPWR sky130_fd_sc_hd__decap_3
XFILLER_50_641 VGND VGND VPWR VPWR sky130_fd_sc_hd__decap_3
X_6866_ _6923_/CLK _6866_/D VGND VGND VPWR VPWR _6866_/Q sky130_fd_sc_hd__dfxtp_2
XFILLER_50_663 VGND VGND VPWR VPWR sky130_fd_sc_hd__decap_3
X_6797_ _6941_/CLK _6797_/D VGND VGND VPWR VPWR _6797_/Q sky130_fd_sc_hd__dfxtp_2
XFILLER_50_696 VGND VGND VPWR VPWR sky130_fd_sc_hd__decap_3
XTAP_TAPCELL_ROW_20_511 VGND VPWR sky130_fd_sc_hd__tapvpwrvgnd_1
XFILLER_2_704 VGND VGND VPWR VPWR sky130_fd_sc_hd__decap_3
XFILLER_104_610 VGND VGND VPWR VPWR sky130_fd_sc_hd__decap_3
XFILLER_1_225 VGND VGND VPWR VPWR sky130_fd_sc_hd__decap_3
XFILLER_89_310 VGND VGND VPWR VPWR sky130_fd_sc_hd__decap_3
X_7349_ _7349_/CLK _7349_/D _6629_/Y VGND VGND VPWR VPWR _7349_/Q sky130_fd_sc_hd__dfrtp_2
XFILLER_103_131 VGND VGND VPWR VPWR sky130_fd_sc_hd__decap_3
XFILLER_104_643 VGND VGND VPWR VPWR sky130_fd_sc_hd__fill_1
XFILLER_104_654 VGND VGND VPWR VPWR sky130_fd_sc_hd__decap_3
XFILLER_1_236 VGND VGND VPWR VPWR sky130_fd_sc_hd__decap_3
XFILLER_77_505 VGND VGND VPWR VPWR sky130_fd_sc_hd__decap_3
XFILLER_89_354 VGND VGND VPWR VPWR sky130_fd_sc_hd__decap_3
XTAP_TAPCELL_ROW_9_369 VGND VPWR sky130_fd_sc_hd__tapvpwrvgnd_1
XFILLER_104_687 VGND VGND VPWR VPWR sky130_fd_sc_hd__decap_3
XFILLER_49_207 VGND VGND VPWR VPWR sky130_fd_sc_hd__decap_3
XFILLER_103_186 VGND VGND VPWR VPWR sky130_fd_sc_hd__decap_3
XFILLER_106_85 VGND VGND VPWR VPWR sky130_fd_sc_hd__decap_3
XFILLER_18_616 VGND VGND VPWR VPWR sky130_fd_sc_hd__decap_3
XFILLER_57_240 VGND VGND VPWR VPWR sky130_fd_sc_hd__fill_1
XFILLER_57_251 VGND VGND VPWR VPWR sky130_fd_sc_hd__decap_3
XFILLER_66_67 VGND VGND VPWR VPWR sky130_fd_sc_hd__decap_3
XFILLER_73_700 VGND VGND VPWR VPWR sky130_fd_sc_hd__decap_3
Xhold1250 _7299_/Q VGND VGND VPWR VPWR _4563_/A sky130_fd_sc_hd__dlygate4sd3_1
Xhold1261 _7139_/Q VGND VGND VPWR VPWR _5388_/A0 sky130_fd_sc_hd__dlygate4sd3_1
XFILLER_45_446 VGND VGND VPWR VPWR sky130_fd_sc_hd__fill_2
Xhold1272 _7236_/Q VGND VGND VPWR VPWR _5184_/A sky130_fd_sc_hd__dlygate4sd3_1
Xhold1283 _7012_/Q VGND VGND VPWR VPWR _5632_/A sky130_fd_sc_hd__dlygate4sd3_1
Xhold1294 _7294_/Q VGND VGND VPWR VPWR _4573_/A sky130_fd_sc_hd__dlygate4sd3_1
XTAP_TAPCELL_ROW_86_1336 VGND VPWR sky130_fd_sc_hd__tapvpwrvgnd_1
XTAP_TAPCELL_ROW_28_611 VGND VPWR sky130_fd_sc_hd__tapvpwrvgnd_1
XFILLER_60_405 VGND VGND VPWR VPWR sky130_fd_sc_hd__decap_3
XTAP_TAPCELL_ROW_56_964 VGND VPWR sky130_fd_sc_hd__tapvpwrvgnd_1
XTAP_TAPCELL_ROW_56_953 VGND VPWR sky130_fd_sc_hd__tapvpwrvgnd_1
XFILLER_26_660 VGND VGND VPWR VPWR sky130_fd_sc_hd__decap_3
XFILLER_26_693 VGND VGND VPWR VPWR sky130_fd_sc_hd__decap_3
XFILLER_60_438 VGND VGND VPWR VPWR sky130_fd_sc_hd__decap_3
XFILLER_72_276 VGND VGND VPWR VPWR sky130_fd_sc_hd__decap_3
XFILLER_13_343 VGND VGND VPWR VPWR sky130_fd_sc_hd__decap_3
XFILLER_41_641 VGND VGND VPWR VPWR sky130_fd_sc_hd__decap_3
XFILLER_82_88 VGND VGND VPWR VPWR sky130_fd_sc_hd__decap_3
XFILLER_41_685 VGND VGND VPWR VPWR sky130_fd_sc_hd__decap_3
XFILLER_9_314 VGND VGND VPWR VPWR sky130_fd_sc_hd__decap_3
XFILLER_40_184 VGND VGND VPWR VPWR sky130_fd_sc_hd__decap_3
XTAP_TAPCELL_ROW_97_1476 VGND VPWR sky130_fd_sc_hd__tapvpwrvgnd_1
XTAP_TAPCELL_ROW_97_1465 VGND VPWR sky130_fd_sc_hd__tapvpwrvgnd_1
XFILLER_5_542 VGND VGND VPWR VPWR sky130_fd_sc_hd__decap_3
XFILLER_5_564 VGND VGND VPWR VPWR sky130_fd_sc_hd__decap_3
XFILLER_5_597 VGND VGND VPWR VPWR sky130_fd_sc_hd__decap_3
XFILLER_68_505 VGND VGND VPWR VPWR sky130_fd_sc_hd__decap_3
XFILLER_110_613 VGND VGND VPWR VPWR sky130_fd_sc_hd__decap_3
XFILLER_68_527 VGND VGND VPWR VPWR sky130_fd_sc_hd__decap_3
XFILLER_110_657 VGND VGND VPWR VPWR sky130_fd_sc_hd__decap_3
XFILLER_68_549 VGND VGND VPWR VPWR sky130_fd_sc_hd__fill_2
XFILLER_48_240 VGND VGND VPWR VPWR sky130_fd_sc_hd__decap_3
XFILLER_48_262 VGND VGND VPWR VPWR sky130_fd_sc_hd__decap_3
XFILLER_76_571 VGND VGND VPWR VPWR sky130_fd_sc_hd__decap_3
XFILLER_95_368 VGND VGND VPWR VPWR sky130_fd_sc_hd__fill_2
XFILLER_36_424 VGND VGND VPWR VPWR sky130_fd_sc_hd__fill_2
XFILLER_36_435 VGND VGND VPWR VPWR sky130_fd_sc_hd__decap_3
XFILLER_63_210 VGND VGND VPWR VPWR sky130_fd_sc_hd__decap_3
XFILLER_24_619 VGND VGND VPWR VPWR sky130_fd_sc_hd__decap_3
XFILLER_36_457 VGND VGND VPWR VPWR sky130_fd_sc_hd__decap_3
XFILLER_63_243 VGND VGND VPWR VPWR sky130_fd_sc_hd__fill_2
XFILLER_91_552 VGND VGND VPWR VPWR sky130_fd_sc_hd__fill_1
XFILLER_17_671 VGND VGND VPWR VPWR sky130_fd_sc_hd__fill_1
XFILLER_17_682 VGND VGND VPWR VPWR sky130_fd_sc_hd__decap_3
XFILLER_23_107 VGND VGND VPWR VPWR sky130_fd_sc_hd__decap_3
XFILLER_63_265 VGND VGND VPWR VPWR sky130_fd_sc_hd__fill_1
X_4981_ _6992_/Q _5001_/A VGND VGND VPWR VPWR _6992_/D sky130_fd_sc_hd__xor2_2
Xclkbuf_leaf_43_clk clkbuf_leaf_1_clk/A VGND VGND VPWR VPWR clkload6/A sky130_fd_sc_hd__clkbuf_16
X_6720_ clkload4/A _6720_/D VGND VGND VPWR VPWR _6720_/Q sky130_fd_sc_hd__dfxtp_2
XTAP_TAPCELL_ROW_106_1583 VGND VPWR sky130_fd_sc_hd__tapvpwrvgnd_1
XFILLER_31_140 VGND VGND VPWR VPWR sky130_fd_sc_hd__decap_3
XFILLER_32_663 VGND VGND VPWR VPWR sky130_fd_sc_hd__decap_3
X_6651_ _6651_/A VGND VGND VPWR VPWR _6651_/Y sky130_fd_sc_hd__inv_2
X_3863_ _6697_/Q _3925_/A2 _3922_/B1 _6875_/Q _3862_/X VGND VGND VPWR VPWR _3863_/X
+ sky130_fd_sc_hd__a221o_2
XFILLER_31_184 VGND VGND VPWR VPWR sky130_fd_sc_hd__decap_3
XFILLER_32_696 VGND VGND VPWR VPWR sky130_fd_sc_hd__decap_3
X_6582_ _6584_/A VGND VGND VPWR VPWR _6582_/Y sky130_fd_sc_hd__inv_2
X_5602_ _5602_/A _5602_/B VGND VGND VPWR VPWR _7026_/D sky130_fd_sc_hd__and2_2
X_3794_ _6774_/Q _3892_/A2 _3879_/B1 _6762_/Q _3793_/X VGND VGND VPWR VPWR _3794_/X
+ sky130_fd_sc_hd__a221o_2
XFILLER_8_391 VGND VGND VPWR VPWR sky130_fd_sc_hd__decap_3
XFILLER_117_267 VGND VGND VPWR VPWR sky130_fd_sc_hd__decap_3
Xoutput611 _5641_/Y VGND VGND VPWR VPWR instruction_out[17] sky130_fd_sc_hd__clkdlybuf4s25_1
Xoutput600 _3741_/B VGND VGND VPWR VPWR alu_result_out[6] sky130_fd_sc_hd__clkdlybuf4s25_1
X_7203_ _7371_/CLK _7203_/D _6483_/Y VGND VGND VPWR VPWR _7203_/Q sky130_fd_sc_hd__dfrtp_2
Xoutput644 _6998_/Q VGND VGND VPWR VPWR pc_out[21] sky130_fd_sc_hd__clkdlybuf4s25_1
Xoutput633 _6988_/Q VGND VGND VPWR VPWR pc_out[11] sky130_fd_sc_hd__clkdlybuf4s25_1
Xoutput622 _4791_/C1 VGND VGND VPWR VPWR instruction_out[2] sky130_fd_sc_hd__clkdlybuf4s25_1
X_4415_ _7400_/Q _4419_/B1 _4434_/B1 _7144_/Q _4414_/X VGND VGND VPWR VPWR _4415_/X
+ sky130_fd_sc_hd__a221o_2
XFILLER_113_440 VGND VGND VPWR VPWR sky130_fd_sc_hd__decap_3
X_7134_ _7362_/CLK _7134_/D _6414_/Y VGND VGND VPWR VPWR _7134_/Q sky130_fd_sc_hd__dfrtp_2
Xoutput655 _7008_/Q VGND VGND VPWR VPWR pc_out[31] sky130_fd_sc_hd__clkdlybuf4s25_1
X_4346_ _7321_/Q _3975_/S _4346_/B1 _7353_/Q VGND VGND VPWR VPWR _4346_/X sky130_fd_sc_hd__a22o_2
XFILLER_99_641 VGND VGND VPWR VPWR sky130_fd_sc_hd__decap_3
XFILLER_59_505 VGND VGND VPWR VPWR sky130_fd_sc_hd__decap_3
XTAP_TAPCELL_ROW_70_1137 VGND VPWR sky130_fd_sc_hd__tapvpwrvgnd_1
XTAP_TAPCELL_ROW_6_339 VGND VPWR sky130_fd_sc_hd__tapvpwrvgnd_1
XTAP_TAPCELL_ROW_6_328 VGND VPWR sky130_fd_sc_hd__tapvpwrvgnd_1
XFILLER_99_685 VGND VGND VPWR VPWR sky130_fd_sc_hd__decap_3
XFILLER_100_134 VGND VGND VPWR VPWR sky130_fd_sc_hd__decap_3
XFILLER_101_635 VGND VGND VPWR VPWR sky130_fd_sc_hd__decap_3
XFILLER_113_495 VGND VGND VPWR VPWR sky130_fd_sc_hd__fill_1
X_7065_ _7387_/CLK _7065_/D _6345_/Y VGND VGND VPWR VPWR _7065_/Q sky130_fd_sc_hd__dfrtp_2
X_4277_ _5003_/A _4987_/A VGND VGND VPWR VPWR _4277_/Y sky130_fd_sc_hd__nor2_2
XFILLER_100_156 VGND VGND VPWR VPWR sky130_fd_sc_hd__decap_3
XFILLER_101_668 VGND VGND VPWR VPWR sky130_fd_sc_hd__decap_3
XFILLER_101_679 VGND VGND VPWR VPWR sky130_fd_sc_hd__decap_3
XFILLER_27_402 VGND VGND VPWR VPWR sky130_fd_sc_hd__fill_1
XFILLER_55_700 VGND VGND VPWR VPWR sky130_fd_sc_hd__decap_3
XFILLER_74_519 VGND VGND VPWR VPWR sky130_fd_sc_hd__decap_3
XFILLER_39_284 VGND VGND VPWR VPWR sky130_fd_sc_hd__decap_3
XFILLER_54_221 VGND VGND VPWR VPWR sky130_fd_sc_hd__decap_3
XFILLER_15_608 VGND VGND VPWR VPWR sky130_fd_sc_hd__decap_3
XFILLER_14_118 VGND VGND VPWR VPWR sky130_fd_sc_hd__decap_3
XFILLER_54_287 VGND VGND VPWR VPWR sky130_fd_sc_hd__decap_3
XTAP_TAPCELL_ROW_53_923 VGND VPWR sky130_fd_sc_hd__tapvpwrvgnd_1
XFILLER_14_129 VGND VGND VPWR VPWR sky130_fd_sc_hd__decap_3
XFILLER_23_641 VGND VGND VPWR VPWR sky130_fd_sc_hd__decap_3
XFILLER_42_438 VGND VGND VPWR VPWR sky130_fd_sc_hd__decap_3
Xclkbuf_leaf_34_clk clkbuf_3_2__f_clk/X VGND VGND VPWR VPWR _7345_/CLK sky130_fd_sc_hd__clkbuf_16
X_6918_ _6922_/CLK _6918_/D VGND VGND VPWR VPWR _6918_/Q sky130_fd_sc_hd__dfxtp_2
XFILLER_23_685 VGND VGND VPWR VPWR sky130_fd_sc_hd__decap_3
X_6849_ _6923_/CLK _6849_/D VGND VGND VPWR VPWR _6849_/Q sky130_fd_sc_hd__dfxtp_2
XTAP_TAPCELL_ROW_81_1266 VGND VPWR sky130_fd_sc_hd__tapvpwrvgnd_1
XFILLER_10_346 VGND VGND VPWR VPWR sky130_fd_sc_hd__decap_3
XFILLER_10_368 VGND VGND VPWR VPWR sky130_fd_sc_hd__decap_3
XFILLER_6_306 VGND VGND VPWR VPWR sky130_fd_sc_hd__fill_2
XFILLER_108_212 VGND VGND VPWR VPWR sky130_fd_sc_hd__decap_3
XFILLER_6_339 VGND VGND VPWR VPWR sky130_fd_sc_hd__decap_3
XFILLER_108_245 VGND VGND VPWR VPWR sky130_fd_sc_hd__decap_3
XFILLER_108_256 VGND VGND VPWR VPWR sky130_fd_sc_hd__decap_3
XFILLER_2_501 VGND VGND VPWR VPWR sky130_fd_sc_hd__decap_3
XFILLER_2_545 VGND VGND VPWR VPWR sky130_fd_sc_hd__decap_3
XFILLER_89_140 VGND VGND VPWR VPWR sky130_fd_sc_hd__decap_3
XFILLER_104_462 VGND VGND VPWR VPWR sky130_fd_sc_hd__decap_3
XFILLER_117_84 VGND VGND VPWR VPWR sky130_fd_sc_hd__decap_3
XFILLER_2_589 VGND VGND VPWR VPWR sky130_fd_sc_hd__decap_3
XFILLER_77_55 VGND VGND VPWR VPWR sky130_fd_sc_hd__fill_1
XFILLER_89_162 VGND VGND VPWR VPWR sky130_fd_sc_hd__fill_1
XFILLER_104_495 VGND VGND VPWR VPWR sky130_fd_sc_hd__decap_3
XFILLER_77_346 VGND VGND VPWR VPWR sky130_fd_sc_hd__decap_3
XFILLER_77_88 VGND VGND VPWR VPWR sky130_fd_sc_hd__decap_3
XFILLER_89_184 VGND VGND VPWR VPWR sky130_fd_sc_hd__decap_3
XFILLER_65_508 VGND VGND VPWR VPWR sky130_fd_sc_hd__decap_3
XFILLER_100_690 VGND VGND VPWR VPWR sky130_fd_sc_hd__decap_3
XFILLER_18_413 VGND VGND VPWR VPWR sky130_fd_sc_hd__decap_3
XFILLER_18_424 VGND VGND VPWR VPWR sky130_fd_sc_hd__decap_3
XFILLER_92_338 VGND VGND VPWR VPWR sky130_fd_sc_hd__fill_2
XFILLER_45_221 VGND VGND VPWR VPWR sky130_fd_sc_hd__decap_3
XFILLER_61_703 VGND VGND VPWR VPWR sky130_fd_sc_hd__decap_3
XFILLER_93_54 VGND VGND VPWR VPWR sky130_fd_sc_hd__fill_2
Xhold1080 _7192_/Q VGND VGND VPWR VPWR _5276_/A0 sky130_fd_sc_hd__dlygate4sd3_1
Xhold1091 _7268_/Q VGND VGND VPWR VPWR _4901_/A0 sky130_fd_sc_hd__dlygate4sd3_1
XFILLER_73_585 VGND VGND VPWR VPWR sky130_fd_sc_hd__decap_3
XFILLER_93_87 VGND VGND VPWR VPWR sky130_fd_sc_hd__decap_3
XFILLER_26_81 VGND VGND VPWR VPWR sky130_fd_sc_hd__decap_3
XFILLER_33_449 VGND VGND VPWR VPWR sky130_fd_sc_hd__decap_3
Xclkbuf_leaf_25_clk clkbuf_3_6__f_clk/X VGND VGND VPWR VPWR _7360_/CLK sky130_fd_sc_hd__clkbuf_16
XFILLER_14_663 VGND VGND VPWR VPWR sky130_fd_sc_hd__decap_3
XFILLER_13_184 VGND VGND VPWR VPWR sky130_fd_sc_hd__fill_1
XFILLER_14_696 VGND VGND VPWR VPWR sky130_fd_sc_hd__decap_3
XFILLER_41_482 VGND VGND VPWR VPWR sky130_fd_sc_hd__fill_1
XFILLER_9_111 VGND VGND VPWR VPWR sky130_fd_sc_hd__fill_1
XFILLER_61_6 VGND VGND VPWR VPWR sky130_fd_sc_hd__fill_1
XTAP_TAPCELL_ROW_11_396 VGND VPWR sky130_fd_sc_hd__tapvpwrvgnd_1
XFILLER_5_361 VGND VGND VPWR VPWR sky130_fd_sc_hd__decap_3
X_4200_ _4200_/A _4381_/A VGND VGND VPWR VPWR _4200_/X sky130_fd_sc_hd__or2_2
XFILLER_96_622 VGND VGND VPWR VPWR sky130_fd_sc_hd__decap_3
XFILLER_110_421 VGND VGND VPWR VPWR sky130_fd_sc_hd__fill_1
X_4131_ _7267_/Q _4131_/A2 _4128_/X _4130_/X VGND VGND VPWR VPWR _4131_/X sky130_fd_sc_hd__a211o_2
XFILLER_37_700 VGND VGND VPWR VPWR sky130_fd_sc_hd__decap_3
XFILLER_68_368 VGND VGND VPWR VPWR sky130_fd_sc_hd__decap_3
XFILLER_95_143 VGND VGND VPWR VPWR sky130_fd_sc_hd__decap_3
XFILLER_96_666 VGND VGND VPWR VPWR sky130_fd_sc_hd__decap_3
XFILLER_96_699 VGND VGND VPWR VPWR sky130_fd_sc_hd__fill_1
X_4062_ _7026_/Q _4131_/A2 _3945_/S _7212_/Q _4061_/X VGND VGND VPWR VPWR _4062_/X
+ sky130_fd_sc_hd__a221o_2
XTAP_TAPCELL_ROW_108_1612 VGND VPWR sky130_fd_sc_hd__tapvpwrvgnd_1
XFILLER_36_221 VGND VGND VPWR VPWR sky130_fd_sc_hd__decap_3
XFILLER_36_243 VGND VGND VPWR VPWR sky130_fd_sc_hd__decap_3
XFILLER_64_541 VGND VGND VPWR VPWR sky130_fd_sc_hd__decap_3
XFILLER_51_202 VGND VGND VPWR VPWR sky130_fd_sc_hd__decap_3
XFILLER_91_360 VGND VGND VPWR VPWR sky130_fd_sc_hd__decap_3
XFILLER_24_438 VGND VGND VPWR VPWR sky130_fd_sc_hd__decap_3
XFILLER_24_449 VGND VGND VPWR VPWR sky130_fd_sc_hd__decap_3
XFILLER_51_246 VGND VGND VPWR VPWR sky130_fd_sc_hd__decap_3
XFILLER_91_393 VGND VGND VPWR VPWR sky130_fd_sc_hd__fill_2
Xclkbuf_leaf_16_clk clkbuf_leaf_9_clk/A VGND VGND VPWR VPWR _7396_/CLK sky130_fd_sc_hd__clkbuf_16
X_4964_ _4910_/A _4961_/X _6994_/D _5666_/A VGND VGND VPWR VPWR _4964_/X sky130_fd_sc_hd__a22o_2
XTAP_TAPCELL_ROW_19_496 VGND VPWR sky130_fd_sc_hd__tapvpwrvgnd_1
XFILLER_32_460 VGND VGND VPWR VPWR sky130_fd_sc_hd__decap_3
XFILLER_51_279 VGND VGND VPWR VPWR sky130_fd_sc_hd__fill_1
X_6703_ _7355_/CLK _6703_/D VGND VGND VPWR VPWR _6703_/Q sky130_fd_sc_hd__dfxtp_2
X_3915_ _3915_/A0 _3914_/X _5151_/A VGND VGND VPWR VPWR _7378_/D sky130_fd_sc_hd__mux2_2
XFILLER_20_622 VGND VGND VPWR VPWR sky130_fd_sc_hd__decap_3
X_4895_ _6997_/Q _4690_/B _4909_/B VGND VGND VPWR VPWR _4896_/B sky130_fd_sc_hd__a21o_2
XFILLER_20_666 VGND VGND VPWR VPWR sky130_fd_sc_hd__decap_3
X_6634_ _6636_/A VGND VGND VPWR VPWR _6634_/Y sky130_fd_sc_hd__inv_2
X_3846_ _6964_/Q _3851_/A2 _3853_/A2 _6952_/Q VGND VGND VPWR VPWR _3846_/X sky130_fd_sc_hd__a22o_2
XFILLER_20_699 VGND VGND VPWR VPWR sky130_fd_sc_hd__fill_1
X_6565_ _6598_/A VGND VGND VPWR VPWR _6565_/Y sky130_fd_sc_hd__inv_2
X_3777_ _6972_/Q _3887_/A2 _3887_/B1 _6722_/Q _3776_/X VGND VGND VPWR VPWR _3777_/X
+ sky130_fd_sc_hd__a221o_2
XTAP_TAPCELL_ROW_119_1752 VGND VPWR sky130_fd_sc_hd__tapvpwrvgnd_1
XTAP_TAPCELL_ROW_119_1741 VGND VPWR sky130_fd_sc_hd__tapvpwrvgnd_1
X_6496_ _6635_/A VGND VGND VPWR VPWR _6496_/Y sky130_fd_sc_hd__inv_2
XTAP_TAPCELL_ROW_119_1763 VGND VPWR sky130_fd_sc_hd__tapvpwrvgnd_1
XFILLER_118_587 VGND VGND VPWR VPWR sky130_fd_sc_hd__fill_1
XFILLER_118_598 VGND VGND VPWR VPWR sky130_fd_sc_hd__decap_3
XFILLER_105_248 VGND VGND VPWR VPWR sky130_fd_sc_hd__decap_3
XFILLER_101_421 VGND VGND VPWR VPWR sky130_fd_sc_hd__decap_3
XFILLER_86_132 VGND VGND VPWR VPWR sky130_fd_sc_hd__decap_3
XFILLER_87_655 VGND VGND VPWR VPWR sky130_fd_sc_hd__decap_3
X_7117_ _7373_/CLK _7117_/D _6397_/Y VGND VGND VPWR VPWR _7117_/Q sky130_fd_sc_hd__dfrtp_2
X_4329_ _4362_/C _4362_/A _4362_/B VGND VGND VPWR VPWR _4330_/B sky130_fd_sc_hd__and3b_2
XFILLER_101_454 VGND VGND VPWR VPWR sky130_fd_sc_hd__decap_3
XFILLER_86_165 VGND VGND VPWR VPWR sky130_fd_sc_hd__decap_3
XFILLER_87_688 VGND VGND VPWR VPWR sky130_fd_sc_hd__decap_3
X_7048_ _7403_/CLK _7048_/D _6328_/Y VGND VGND VPWR VPWR _7048_/Q sky130_fd_sc_hd__dfrtp_2
XFILLER_101_476 VGND VGND VPWR VPWR sky130_fd_sc_hd__decap_3
XFILLER_27_210 VGND VGND VPWR VPWR sky130_fd_sc_hd__decap_3
XPHY_EDGE_ROW_114_Right_114 VGND VGND VPWR VPWR sky130_fd_sc_hd__decap_3
XFILLER_103_20 VGND VGND VPWR VPWR sky130_fd_sc_hd__fill_1
XFILLER_27_243 VGND VGND VPWR VPWR sky130_fd_sc_hd__decap_3
XFILLER_67_390 VGND VGND VPWR VPWR sky130_fd_sc_hd__fill_2
XFILLER_103_75 VGND VGND VPWR VPWR sky130_fd_sc_hd__fill_2
XFILLER_27_276 VGND VGND VPWR VPWR sky130_fd_sc_hd__decap_3
XFILLER_43_703 VGND VGND VPWR VPWR sky130_fd_sc_hd__decap_3
XFILLER_70_500 VGND VGND VPWR VPWR sky130_fd_sc_hd__decap_3
XFILLER_82_371 VGND VGND VPWR VPWR sky130_fd_sc_hd__fill_2
XFILLER_103_97 VGND VGND VPWR VPWR sky130_fd_sc_hd__decap_3
XFILLER_27_287 VGND VGND VPWR VPWR sky130_fd_sc_hd__decap_3
XFILLER_70_533 VGND VGND VPWR VPWR sky130_fd_sc_hd__fill_2
XFILLER_11_600 VGND VGND VPWR VPWR sky130_fd_sc_hd__decap_3
XFILLER_42_268 VGND VGND VPWR VPWR sky130_fd_sc_hd__fill_1
XFILLER_23_460 VGND VGND VPWR VPWR sky130_fd_sc_hd__decap_3
XFILLER_11_644 VGND VGND VPWR VPWR sky130_fd_sc_hd__decap_3
XFILLER_50_290 VGND VGND VPWR VPWR sky130_fd_sc_hd__decap_3
XFILLER_7_615 VGND VGND VPWR VPWR sky130_fd_sc_hd__fill_1
XFILLER_11_688 VGND VGND VPWR VPWR sky130_fd_sc_hd__decap_3
XFILLER_7_626 VGND VGND VPWR VPWR sky130_fd_sc_hd__decap_3
XFILLER_109_554 VGND VGND VPWR VPWR sky130_fd_sc_hd__fill_1
XFILLER_6_147 VGND VGND VPWR VPWR sky130_fd_sc_hd__decap_3
XFILLER_7_659 VGND VGND VPWR VPWR sky130_fd_sc_hd__decap_3
XFILLER_109_587 VGND VGND VPWR VPWR sky130_fd_sc_hd__decap_3
XTAP_TAPCELL_ROW_94_1435 VGND VPWR sky130_fd_sc_hd__tapvpwrvgnd_1
XFILLER_2_353 VGND VGND VPWR VPWR sky130_fd_sc_hd__decap_3
XFILLER_88_76 VGND VGND VPWR VPWR sky130_fd_sc_hd__decap_3
XFILLER_19_700 VGND VGND VPWR VPWR sky130_fd_sc_hd__decap_3
XFILLER_78_666 VGND VGND VPWR VPWR sky130_fd_sc_hd__decap_3
XFILLER_65_316 VGND VGND VPWR VPWR sky130_fd_sc_hd__decap_3
XFILLER_78_699 VGND VGND VPWR VPWR sky130_fd_sc_hd__fill_1
XFILLER_92_124 VGND VGND VPWR VPWR sky130_fd_sc_hd__decap_3
XFILLER_93_647 VGND VGND VPWR VPWR sky130_fd_sc_hd__decap_3
XFILLER_58_390 VGND VGND VPWR VPWR sky130_fd_sc_hd__decap_3
XTAP_TAPCELL_ROW_36_709 VGND VPWR sky130_fd_sc_hd__tapvpwrvgnd_1
XFILLER_73_371 VGND VGND VPWR VPWR sky130_fd_sc_hd__decap_3
XFILLER_92_168 VGND VGND VPWR VPWR sky130_fd_sc_hd__decap_3
XFILLER_18_287 VGND VGND VPWR VPWR sky130_fd_sc_hd__decap_3
XFILLER_33_213 VGND VGND VPWR VPWR sky130_fd_sc_hd__decap_3
XFILLER_33_257 VGND VGND VPWR VPWR sky130_fd_sc_hd__decap_3
XTAP_TAPCELL_ROW_16_455 VGND VPWR sky130_fd_sc_hd__tapvpwrvgnd_1
XTAP_TAPCELL_ROW_103_1542 VGND VPWR sky130_fd_sc_hd__tapvpwrvgnd_1
XFILLER_14_460 VGND VGND VPWR VPWR sky130_fd_sc_hd__decap_3
XFILLER_61_599 VGND VGND VPWR VPWR sky130_fd_sc_hd__decap_3
X_3700_ _6939_/Q _3760_/A2 _3759_/A2 _6803_/Q _3699_/X VGND VGND VPWR VPWR _3700_/X
+ sky130_fd_sc_hd__a221o_2
X_4680_ _4680_/A _5015_/B VGND VGND VPWR VPWR _5009_/A sky130_fd_sc_hd__nor2_2
XFILLER_119_329 VGND VGND VPWR VPWR sky130_fd_sc_hd__decap_3
X_3631_ _3630_/A _3630_/B _3605_/Y VGND VGND VPWR VPWR _3631_/Y sky130_fd_sc_hd__o21ai_2
X_6350_ _6677_/A VGND VGND VPWR VPWR _6350_/Y sky130_fd_sc_hd__inv_2
X_3562_ _3562_/A _3562_/B _3561_/X VGND VGND VPWR VPWR _5362_/C sky130_fd_sc_hd__or3b_2
XFILLER_115_524 VGND VGND VPWR VPWR sky130_fd_sc_hd__decap_3
XFILLER_6_681 VGND VGND VPWR VPWR sky130_fd_sc_hd__decap_3
XFILLER_115_557 VGND VGND VPWR VPWR sky130_fd_sc_hd__decap_3
XFILLER_5_180 VGND VGND VPWR VPWR sky130_fd_sc_hd__decap_3
X_6281_ _6621_/A VGND VGND VPWR VPWR _6281_/Y sky130_fd_sc_hd__inv_2
X_3493_ _7087_/Q _3417_/X _3407_/X _7119_/Q VGND VGND VPWR VPWR _3493_/X sky130_fd_sc_hd__a22o_2
XFILLER_102_207 VGND VGND VPWR VPWR sky130_fd_sc_hd__decap_3
XFILLER_88_419 VGND VGND VPWR VPWR sky130_fd_sc_hd__fill_1
Xclkbuf_leaf_5_clk clkbuf_leaf_6_clk/A VGND VGND VPWR VPWR _6923_/CLK sky130_fd_sc_hd__clkbuf_16
X_5232_ _5232_/A0 _4716_/X _5272_/S VGND VGND VPWR VPWR _7214_/D sky130_fd_sc_hd__mux2_2
XTAP_TAPCELL_ROW_114_1682 VGND VPWR sky130_fd_sc_hd__tapvpwrvgnd_1
XFILLER_69_644 VGND VGND VPWR VPWR sky130_fd_sc_hd__decap_3
X_5163_ _5163_/A _5198_/B VGND VGND VPWR VPWR _7246_/D sky130_fd_sc_hd__and2_2
XFILLER_29_508 VGND VGND VPWR VPWR sky130_fd_sc_hd__decap_3
XFILLER_56_305 VGND VGND VPWR VPWR sky130_fd_sc_hd__decap_3
XFILLER_69_688 VGND VGND VPWR VPWR sky130_fd_sc_hd__decap_3
XFILLER_96_441 VGND VGND VPWR VPWR sky130_fd_sc_hd__fill_1
XFILLER_96_463 VGND VGND VPWR VPWR sky130_fd_sc_hd__decap_3
X_4114_ _7172_/Q _3366_/X _4263_/A2 _7140_/Q _4113_/X VGND VGND VPWR VPWR _4114_/X
+ sky130_fd_sc_hd__a221o_2
XFILLER_110_262 VGND VGND VPWR VPWR sky130_fd_sc_hd__decap_3
XFILLER_56_327 VGND VGND VPWR VPWR sky130_fd_sc_hd__decap_3
XFILLER_68_165 VGND VGND VPWR VPWR sky130_fd_sc_hd__decap_3
XFILLER_83_113 VGND VGND VPWR VPWR sky130_fd_sc_hd__decap_3
XFILLER_84_625 VGND VGND VPWR VPWR sky130_fd_sc_hd__decap_3
X_5094_ _4606_/A _6986_/D _5093_/X VGND VGND VPWR VPWR _5094_/X sky130_fd_sc_hd__a21o_2
XFILLER_37_530 VGND VGND VPWR VPWR sky130_fd_sc_hd__fill_1
XFILLER_49_390 VGND VGND VPWR VPWR sky130_fd_sc_hd__fill_2
XFILLER_84_669 VGND VGND VPWR VPWR sky130_fd_sc_hd__decap_3
X_4045_ _7085_/Q _4102_/B _4432_/B1 _4044_/X VGND VGND VPWR VPWR _4054_/A sky130_fd_sc_hd__o211a_2
XFILLER_25_703 VGND VGND VPWR VPWR sky130_fd_sc_hd__decap_3
XFILLER_64_371 VGND VGND VPWR VPWR sky130_fd_sc_hd__decap_3
XFILLER_24_224 VGND VGND VPWR VPWR sky130_fd_sc_hd__decap_3
XFILLER_37_596 VGND VGND VPWR VPWR sky130_fd_sc_hd__decap_3
XFILLER_91_190 VGND VGND VPWR VPWR sky130_fd_sc_hd__decap_3
XFILLER_12_408 VGND VGND VPWR VPWR sky130_fd_sc_hd__decap_3
XFILLER_12_419 VGND VGND VPWR VPWR sky130_fd_sc_hd__fill_1
XTAP_TAPCELL_ROW_65_1069 VGND VPWR sky130_fd_sc_hd__tapvpwrvgnd_1
XFILLER_32_290 VGND VGND VPWR VPWR sky130_fd_sc_hd__decap_3
X_4878_ _5666_/A _6999_/D _4870_/Y _4877_/X VGND VGND VPWR VPWR _4878_/X sky130_fd_sc_hd__a211o_2
X_6617_ _6617_/A VGND VGND VPWR VPWR _6617_/Y sky130_fd_sc_hd__inv_2
X_3829_ _6908_/Q _3912_/A2 _3912_/B1 _6900_/Q VGND VGND VPWR VPWR _3829_/X sky130_fd_sc_hd__a22o_2
XPHY_EDGE_ROW_104_Left_224 VGND VGND VPWR VPWR sky130_fd_sc_hd__decap_3
XFILLER_4_629 VGND VGND VPWR VPWR sky130_fd_sc_hd__decap_3
X_6548_ _6642_/A VGND VGND VPWR VPWR _6548_/Y sky130_fd_sc_hd__inv_2
XFILLER_109_6 VGND VGND VPWR VPWR sky130_fd_sc_hd__decap_3
X_6479_ _6544_/A VGND VGND VPWR VPWR _6479_/Y sky130_fd_sc_hd__inv_2
XFILLER_59_143 VGND VGND VPWR VPWR sky130_fd_sc_hd__decap_3
XFILLER_87_452 VGND VGND VPWR VPWR sky130_fd_sc_hd__decap_3
XFILLER_101_273 VGND VGND VPWR VPWR sky130_fd_sc_hd__decap_3
XFILLER_114_41 VGND VGND VPWR VPWR sky130_fd_sc_hd__decap_3
XFILLER_47_316 VGND VGND VPWR VPWR sky130_fd_sc_hd__fill_2
XFILLER_75_647 VGND VGND VPWR VPWR sky130_fd_sc_hd__decap_3
XFILLER_87_485 VGND VGND VPWR VPWR sky130_fd_sc_hd__decap_3
XPHY_EDGE_ROW_113_Left_233 VGND VGND VPWR VPWR sky130_fd_sc_hd__decap_3
XFILLER_101_295 VGND VGND VPWR VPWR sky130_fd_sc_hd__decap_3
XFILLER_114_74 VGND VGND VPWR VPWR sky130_fd_sc_hd__decap_3
XFILLER_114_85 VGND VGND VPWR VPWR sky130_fd_sc_hd__decap_3
XFILLER_74_124 VGND VGND VPWR VPWR sky130_fd_sc_hd__decap_3
XFILLER_28_585 VGND VGND VPWR VPWR sky130_fd_sc_hd__decap_3
XFILLER_43_511 VGND VGND VPWR VPWR sky130_fd_sc_hd__decap_3
XFILLER_74_168 VGND VGND VPWR VPWR sky130_fd_sc_hd__decap_3
XFILLER_74_56 VGND VGND VPWR VPWR sky130_fd_sc_hd__decap_3
XFILLER_90_628 VGND VGND VPWR VPWR sky130_fd_sc_hd__decap_3
XFILLER_43_522 VGND VGND VPWR VPWR sky130_fd_sc_hd__decap_3
XFILLER_83_691 VGND VGND VPWR VPWR sky130_fd_sc_hd__decap_3
XFILLER_31_706 VGND VGND VPWR VPWR sky130_fd_sc_hd__decap_3
XFILLER_70_374 VGND VGND VPWR VPWR sky130_fd_sc_hd__decap_3
XFILLER_23_290 VGND VGND VPWR VPWR sky130_fd_sc_hd__decap_3
XFILLER_30_238 VGND VGND VPWR VPWR sky130_fd_sc_hd__decap_3
XFILLER_90_88 VGND VGND VPWR VPWR sky130_fd_sc_hd__decap_3
XTAP_TAPCELL_ROW_41_767 VGND VPWR sky130_fd_sc_hd__tapvpwrvgnd_1
XTAP_TAPCELL_ROW_13_425 VGND VPWR sky130_fd_sc_hd__tapvpwrvgnd_1
XFILLER_109_340 VGND VGND VPWR VPWR sky130_fd_sc_hd__fill_1
XFILLER_11_485 VGND VGND VPWR VPWR sky130_fd_sc_hd__decap_3
XFILLER_7_434 VGND VGND VPWR VPWR sky130_fd_sc_hd__decap_3
XFILLER_99_20 VGND VGND VPWR VPWR sky130_fd_sc_hd__decap_3
XFILLER_7_478 VGND VGND VPWR VPWR sky130_fd_sc_hd__decap_3
XFILLER_112_505 VGND VGND VPWR VPWR sky130_fd_sc_hd__decap_3
XFILLER_3_662 VGND VGND VPWR VPWR sky130_fd_sc_hd__decap_3
XFILLER_3_673 VGND VGND VPWR VPWR sky130_fd_sc_hd__decap_3
XFILLER_97_216 VGND VGND VPWR VPWR sky130_fd_sc_hd__decap_3
XFILLER_112_538 VGND VGND VPWR VPWR sky130_fd_sc_hd__decap_3
XFILLER_78_430 VGND VGND VPWR VPWR sky130_fd_sc_hd__decap_3
XFILLER_65_113 VGND VGND VPWR VPWR sky130_fd_sc_hd__decap_3
XFILLER_66_614 VGND VGND VPWR VPWR sky130_fd_sc_hd__decap_3
XFILLER_65_146 VGND VGND VPWR VPWR sky130_fd_sc_hd__decap_3
XFILLER_66_669 VGND VGND VPWR VPWR sky130_fd_sc_hd__decap_3
XTAP_TAPCELL_ROW_49_867 VGND VPWR sky130_fd_sc_hd__tapvpwrvgnd_1
XFILLER_19_574 VGND VGND VPWR VPWR sky130_fd_sc_hd__decap_3
XFILLER_81_617 VGND VGND VPWR VPWR sky130_fd_sc_hd__decap_3
XFILLER_93_488 VGND VGND VPWR VPWR sky130_fd_sc_hd__decap_3
XFILLER_34_511 VGND VGND VPWR VPWR sky130_fd_sc_hd__decap_3
XFILLER_34_533 VGND VGND VPWR VPWR sky130_fd_sc_hd__decap_3
XFILLER_80_127 VGND VGND VPWR VPWR sky130_fd_sc_hd__decap_3
XFILLER_61_374 VGND VGND VPWR VPWR sky130_fd_sc_hd__decap_3
X_4801_ _4801_/A _4801_/B VGND VGND VPWR VPWR _7003_/D sky130_fd_sc_hd__nor2_2
XFILLER_9_51 VGND VGND VPWR VPWR sky130_fd_sc_hd__decap_3
X_4663_ _4764_/B _4040_/B _4608_/Y _4659_/X _4662_/Y VGND VGND VPWR VPWR _5665_/A
+ sky130_fd_sc_hd__o32a_2
XFILLER_9_84 VGND VGND VPWR VPWR sky130_fd_sc_hd__fill_2
X_6402_ _6626_/A VGND VGND VPWR VPWR _6402_/Y sky130_fd_sc_hd__inv_2
X_3614_ _3614_/A _3614_/B VGND VGND VPWR VPWR _3746_/B sky130_fd_sc_hd__and2_2
X_7382_ clkload4/A _7382_/D _6662_/Y VGND VGND VPWR VPWR _7382_/Q sky130_fd_sc_hd__dfrtp_2
Xhold902 _6968_/Q VGND VGND VPWR VPWR _6968_/D sky130_fd_sc_hd__dlygate4sd3_1
Xhold913 _6930_/Q VGND VGND VPWR VPWR _6930_/D sky130_fd_sc_hd__dlygate4sd3_1
XTAP_TAPCELL_ROW_116_1711 VGND VPWR sky130_fd_sc_hd__tapvpwrvgnd_1
XFILLER_115_321 VGND VGND VPWR VPWR sky130_fd_sc_hd__decap_3
XFILLER_115_343 VGND VGND VPWR VPWR sky130_fd_sc_hd__decap_3
XFILLER_89_706 VGND VGND VPWR VPWR sky130_fd_sc_hd__decap_3
Xhold924 _6885_/Q VGND VGND VPWR VPWR _6885_/D sky130_fd_sc_hd__dlygate4sd3_1
Xhold935 _6882_/Q VGND VGND VPWR VPWR _6882_/D sky130_fd_sc_hd__dlygate4sd3_1
Xhold946 _7069_/Q VGND VGND VPWR VPWR _7069_/D sky130_fd_sc_hd__dlygate4sd3_1
X_6333_ _6557_/A VGND VGND VPWR VPWR _6333_/Y sky130_fd_sc_hd__inv_2
X_3545_ _3545_/A _3545_/B VGND VGND VPWR VPWR _3636_/A sky130_fd_sc_hd__nor2_2
XFILLER_103_505 VGND VGND VPWR VPWR sky130_fd_sc_hd__decap_3
Xhold957 _7055_/Q VGND VGND VPWR VPWR _7055_/D sky130_fd_sc_hd__dlygate4sd3_1
Xhold968 _7106_/Q VGND VGND VPWR VPWR _7106_/D sky130_fd_sc_hd__dlygate4sd3_1
Xhold979 _7064_/Q VGND VGND VPWR VPWR _7064_/D sky130_fd_sc_hd__dlygate4sd3_1
Xmax_cap676 _4467_/Y VGND VGND VPWR VPWR _5581_/S sky130_fd_sc_hd__buf_2
Xmax_cap665 _4610_/A VGND VGND VPWR VPWR _4745_/A sky130_fd_sc_hd__clkbuf_2
X_6264_ _6662_/A VGND VGND VPWR VPWR _6264_/Y sky130_fd_sc_hd__inv_2
X_3476_ _7056_/Q _4305_/B _3590_/A VGND VGND VPWR VPWR _3502_/B sky130_fd_sc_hd__o21ai_2
XFILLER_88_227 VGND VGND VPWR VPWR sky130_fd_sc_hd__decap_3
X_5215_ _5215_/A _5225_/B VGND VGND VPWR VPWR _7221_/D sky130_fd_sc_hd__and2_2
XFILLER_69_463 VGND VGND VPWR VPWR sky130_fd_sc_hd__decap_3
XFILLER_111_582 VGND VGND VPWR VPWR sky130_fd_sc_hd__decap_3
XFILLER_28_38 VGND VGND VPWR VPWR sky130_fd_sc_hd__decap_3
XFILLER_29_316 VGND VGND VPWR VPWR sky130_fd_sc_hd__decap_3
XFILLER_57_614 VGND VGND VPWR VPWR sky130_fd_sc_hd__fill_2
XFILLER_84_411 VGND VGND VPWR VPWR sky130_fd_sc_hd__decap_3
X_5146_ _5145_/A _3541_/X _3605_/Y VGND VGND VPWR VPWR _5146_/Y sky130_fd_sc_hd__o21ai_2
XFILLER_29_349 VGND VGND VPWR VPWR sky130_fd_sc_hd__decap_3
XFILLER_56_124 VGND VGND VPWR VPWR sky130_fd_sc_hd__decap_3
XFILLER_57_647 VGND VGND VPWR VPWR sky130_fd_sc_hd__decap_3
XFILLER_84_433 VGND VGND VPWR VPWR sky130_fd_sc_hd__fill_2
X_5077_ _3864_/S _3863_/X _5658_/A VGND VGND VPWR VPWR _5077_/X sky130_fd_sc_hd__a21o_2
XFILLER_56_168 VGND VGND VPWR VPWR sky130_fd_sc_hd__decap_3
XFILLER_71_105 VGND VGND VPWR VPWR sky130_fd_sc_hd__decap_3
XFILLER_72_628 VGND VGND VPWR VPWR sky130_fd_sc_hd__decap_3
XFILLER_84_488 VGND VGND VPWR VPWR sky130_fd_sc_hd__fill_2
XFILLER_37_393 VGND VGND VPWR VPWR sky130_fd_sc_hd__fill_1
XFILLER_44_26 VGND VGND VPWR VPWR sky130_fd_sc_hd__fill_2
XFILLER_65_691 VGND VGND VPWR VPWR sky130_fd_sc_hd__decap_3
XFILLER_71_116 VGND VGND VPWR VPWR sky130_fd_sc_hd__decap_3
XFILLER_13_706 VGND VGND VPWR VPWR sky130_fd_sc_hd__decap_3
XFILLER_25_555 VGND VGND VPWR VPWR sky130_fd_sc_hd__decap_3
XFILLER_44_48 VGND VGND VPWR VPWR sky130_fd_sc_hd__decap_3
XFILLER_52_352 VGND VGND VPWR VPWR sky130_fd_sc_hd__decap_3
XFILLER_100_21 VGND VGND VPWR VPWR sky130_fd_sc_hd__decap_3
XFILLER_40_536 VGND VGND VPWR VPWR sky130_fd_sc_hd__decap_3
XFILLER_52_374 VGND VGND VPWR VPWR sky130_fd_sc_hd__decap_3
XFILLER_80_672 VGND VGND VPWR VPWR sky130_fd_sc_hd__decap_3
XFILLER_40_569 VGND VGND VPWR VPWR sky130_fd_sc_hd__decap_3
XFILLER_20_271 VGND VGND VPWR VPWR sky130_fd_sc_hd__decap_3
XTAP_TAPCELL_ROW_78_1227 VGND VPWR sky130_fd_sc_hd__tapvpwrvgnd_1
XFILLER_109_30 VGND VGND VPWR VPWR sky130_fd_sc_hd__decap_3
XFILLER_4_415 VGND VGND VPWR VPWR sky130_fd_sc_hd__decap_3
XTAP_TAPCELL_ROW_78_1238 VGND VPWR sky130_fd_sc_hd__tapvpwrvgnd_1
XFILLER_106_321 VGND VGND VPWR VPWR sky130_fd_sc_hd__fill_2
XFILLER_107_3 VGND VGND VPWR VPWR sky130_fd_sc_hd__decap_3
XFILLER_109_63 VGND VGND VPWR VPWR sky130_fd_sc_hd__decap_3
XFILLER_119_693 VGND VGND VPWR VPWR sky130_fd_sc_hd__decap_3
XFILLER_106_365 VGND VGND VPWR VPWR sky130_fd_sc_hd__decap_3
XFILLER_69_34 VGND VGND VPWR VPWR sky130_fd_sc_hd__fill_2
XFILLER_106_398 VGND VGND VPWR VPWR sky130_fd_sc_hd__decap_3
XFILLER_79_216 VGND VGND VPWR VPWR sky130_fd_sc_hd__decap_3
XFILLER_79_249 VGND VGND VPWR VPWR sky130_fd_sc_hd__decap_3
XFILLER_0_632 VGND VGND VPWR VPWR sky130_fd_sc_hd__fill_2
XFILLER_0_654 VGND VGND VPWR VPWR sky130_fd_sc_hd__decap_3
XFILLER_95_709 VGND VGND VPWR VPWR sky130_fd_sc_hd__decap_3
XFILLER_0_676 VGND VGND VPWR VPWR sky130_fd_sc_hd__decap_3
XFILLER_47_113 VGND VGND VPWR VPWR sky130_fd_sc_hd__fill_2
XFILLER_48_614 VGND VGND VPWR VPWR sky130_fd_sc_hd__decap_3
XFILLER_75_411 VGND VGND VPWR VPWR sky130_fd_sc_hd__fill_1
XFILLER_102_593 VGND VGND VPWR VPWR sky130_fd_sc_hd__fill_2
XFILLER_48_669 VGND VGND VPWR VPWR sky130_fd_sc_hd__decap_3
XFILLER_85_55 VGND VGND VPWR VPWR sky130_fd_sc_hd__fill_1
XFILLER_85_66 VGND VGND VPWR VPWR sky130_fd_sc_hd__decap_3
XFILLER_62_105 VGND VGND VPWR VPWR sky130_fd_sc_hd__decap_3
XFILLER_63_617 VGND VGND VPWR VPWR sky130_fd_sc_hd__decap_3
XFILLER_85_99 VGND VGND VPWR VPWR sky130_fd_sc_hd__decap_3
XTAP_TAPCELL_ROW_89_1367 VGND VPWR sky130_fd_sc_hd__tapvpwrvgnd_1
XFILLER_18_82 VGND VGND VPWR VPWR sky130_fd_sc_hd__fill_2
XTAP_TAPCELL_ROW_46_837 VGND VPWR sky130_fd_sc_hd__tapvpwrvgnd_1
XFILLER_55_190 VGND VGND VPWR VPWR sky130_fd_sc_hd__fill_1
XFILLER_71_650 VGND VGND VPWR VPWR sky130_fd_sc_hd__decap_3
XFILLER_90_458 VGND VGND VPWR VPWR sky130_fd_sc_hd__decap_3
XFILLER_31_525 VGND VGND VPWR VPWR sky130_fd_sc_hd__decap_3
XFILLER_70_171 VGND VGND VPWR VPWR sky130_fd_sc_hd__decap_3
XFILLER_71_694 VGND VGND VPWR VPWR sky130_fd_sc_hd__decap_3
XTAP_TAPCELL_ROW_26_583 VGND VPWR sky130_fd_sc_hd__tapvpwrvgnd_1
XTAP_TAPCELL_ROW_100_1512 VGND VPWR sky130_fd_sc_hd__tapvpwrvgnd_1
XFILLER_8_710 VGND VGND VPWR VPWR sky130_fd_sc_hd__decap_3
XFILLER_109_181 VGND VGND VPWR VPWR sky130_fd_sc_hd__decap_3
XFILLER_50_91 VGND VGND VPWR VPWR sky130_fd_sc_hd__fill_1
XFILLER_98_514 VGND VGND VPWR VPWR sky130_fd_sc_hd__decap_3
X_3330_ _3330_/A VGND VGND VPWR VPWR _3330_/Y sky130_fd_sc_hd__inv_2
XFILLER_112_302 VGND VGND VPWR VPWR sky130_fd_sc_hd__decap_3
XFILLER_3_481 VGND VGND VPWR VPWR sky130_fd_sc_hd__decap_3
XFILLER_98_536 VGND VGND VPWR VPWR sky130_fd_sc_hd__decap_3
XFILLER_112_346 VGND VGND VPWR VPWR sky130_fd_sc_hd__decap_3
XFILLER_112_368 VGND VGND VPWR VPWR sky130_fd_sc_hd__decap_3
XFILLER_98_569 VGND VGND VPWR VPWR sky130_fd_sc_hd__decap_3
X_5000_ _6991_/Q _5026_/A VGND VGND VPWR VPWR _5001_/B sky130_fd_sc_hd__nor2_2
XTAP_TAPCELL_ROW_111_1641 VGND VPWR sky130_fd_sc_hd__tapvpwrvgnd_1
XFILLER_100_519 VGND VGND VPWR VPWR sky130_fd_sc_hd__fill_2
XFILLER_85_219 VGND VGND VPWR VPWR sky130_fd_sc_hd__decap_3
Xsingle_cycle_cpu VGND VGND VPWR VPWR single_cycle_cpu/HI instruction_out[19] sky130_fd_sc_hd__conb_1
XFILLER_38_113 VGND VGND VPWR VPWR sky130_fd_sc_hd__fill_2
XFILLER_38_124 VGND VGND VPWR VPWR sky130_fd_sc_hd__decap_3
XFILLER_39_647 VGND VGND VPWR VPWR sky130_fd_sc_hd__decap_3
XFILLER_38_179 VGND VGND VPWR VPWR sky130_fd_sc_hd__decap_3
XFILLER_66_477 VGND VGND VPWR VPWR sky130_fd_sc_hd__decap_3
XFILLER_93_263 VGND VGND VPWR VPWR sky130_fd_sc_hd__decap_3
XFILLER_19_360 VGND VGND VPWR VPWR sky130_fd_sc_hd__decap_3
XFILLER_19_382 VGND VGND VPWR VPWR sky130_fd_sc_hd__fill_1
XFILLER_19_393 VGND VGND VPWR VPWR sky130_fd_sc_hd__decap_3
XFILLER_47_691 VGND VGND VPWR VPWR sky130_fd_sc_hd__decap_3
XFILLER_53_116 VGND VGND VPWR VPWR sky130_fd_sc_hd__fill_2
XFILLER_54_639 VGND VGND VPWR VPWR sky130_fd_sc_hd__decap_3
XFILLER_93_296 VGND VGND VPWR VPWR sky130_fd_sc_hd__decap_3
X_6951_ clkload6/A _6951_/D VGND VGND VPWR VPWR _6951_/Q sky130_fd_sc_hd__dfxtp_2
XFILLER_34_330 VGND VGND VPWR VPWR sky130_fd_sc_hd__decap_3
X_6882_ _7189_/CLK _6882_/D VGND VGND VPWR VPWR _6882_/Q sky130_fd_sc_hd__dfxtp_2
XFILLER_34_363 VGND VGND VPWR VPWR sky130_fd_sc_hd__fill_1
XFILLER_62_672 VGND VGND VPWR VPWR sky130_fd_sc_hd__decap_3
XTAP_TAPCELL_ROW_62_1028 VGND VPWR sky130_fd_sc_hd__tapvpwrvgnd_1
XFILLER_14_29 VGND VGND VPWR VPWR sky130_fd_sc_hd__fill_2
XTAP_TAPCELL_ROW_62_1039 VGND VPWR sky130_fd_sc_hd__tapvpwrvgnd_1
X_5695_ _7353_/Q _5695_/A1 _5721_/S VGND VGND VPWR VPWR _6697_/D sky130_fd_sc_hd__mux2_2
XFILLER_108_619 VGND VGND VPWR VPWR sky130_fd_sc_hd__decap_3
X_4646_ _4646_/A _4646_/B VGND VGND VPWR VPWR _4646_/Y sky130_fd_sc_hd__nand2_2
X_7365_ _7370_/CLK _7365_/D _6645_/Y VGND VGND VPWR VPWR _7365_/Q sky130_fd_sc_hd__dfrtp_2
Xhold710 _6934_/Q VGND VGND VPWR VPWR _6934_/D sky130_fd_sc_hd__dlygate4sd3_1
Xhold721 _6828_/Q VGND VGND VPWR VPWR _6828_/D sky130_fd_sc_hd__dlygate4sd3_1
X_4577_ _4577_/A _4577_/B VGND VGND VPWR VPWR _7292_/D sky130_fd_sc_hd__and2_2
XFILLER_116_663 VGND VGND VPWR VPWR sky130_fd_sc_hd__decap_3
Xhold732 _6774_/Q VGND VGND VPWR VPWR _6774_/D sky130_fd_sc_hd__dlygate4sd3_1
Xhold743 _6929_/Q VGND VGND VPWR VPWR _6929_/D sky130_fd_sc_hd__dlygate4sd3_1
Xhold754 _6913_/Q VGND VGND VPWR VPWR _6913_/D sky130_fd_sc_hd__dlygate4sd3_1
X_6316_ _6667_/A VGND VGND VPWR VPWR _6316_/Y sky130_fd_sc_hd__inv_2
XFILLER_103_324 VGND VGND VPWR VPWR sky130_fd_sc_hd__decap_3
XFILLER_116_696 VGND VGND VPWR VPWR sky130_fd_sc_hd__decap_3
X_7296_ _7333_/CLK _7296_/D _6576_/Y VGND VGND VPWR VPWR _7296_/Q sky130_fd_sc_hd__dfrtp_2
Xhold765 _6843_/Q VGND VGND VPWR VPWR _6843_/D sky130_fd_sc_hd__dlygate4sd3_1
Xhold776 _6927_/Q VGND VGND VPWR VPWR _6927_/D sky130_fd_sc_hd__dlygate4sd3_1
Xhold787 _6845_/Q VGND VGND VPWR VPWR _6845_/D sky130_fd_sc_hd__dlygate4sd3_1
X_3528_ _3528_/A _5118_/D VGND VGND VPWR VPWR _5659_/A sky130_fd_sc_hd__or2_2
XFILLER_103_368 VGND VGND VPWR VPWR sky130_fd_sc_hd__decap_3
XFILLER_39_37 VGND VGND VPWR VPWR sky130_fd_sc_hd__decap_3
XFILLER_77_709 VGND VGND VPWR VPWR sky130_fd_sc_hd__decap_3
Xhold798 _6723_/Q VGND VGND VPWR VPWR _6723_/D sky130_fd_sc_hd__dlygate4sd3_1
X_3459_ _7217_/Q _4349_/B1 _4348_/B1 _7121_/Q VGND VGND VPWR VPWR _3459_/X sky130_fd_sc_hd__a22o_2
XTAP_TAPCELL_ROW_73_1168 VGND VPWR sky130_fd_sc_hd__tapvpwrvgnd_1
XFILLER_76_219 VGND VGND VPWR VPWR sky130_fd_sc_hd__fill_1
XFILLER_57_444 VGND VGND VPWR VPWR sky130_fd_sc_hd__decap_3
XFILLER_69_293 VGND VGND VPWR VPWR sky130_fd_sc_hd__decap_3
XFILLER_84_230 VGND VGND VPWR VPWR sky130_fd_sc_hd__decap_3
X_5129_ _5129_/A _5129_/B VGND VGND VPWR VPWR _5130_/C sky130_fd_sc_hd__nor2_2
XFILLER_45_617 VGND VGND VPWR VPWR sky130_fd_sc_hd__decap_3
XFILLER_55_14 VGND VGND VPWR VPWR sky130_fd_sc_hd__decap_3
XFILLER_72_403 VGND VGND VPWR VPWR sky130_fd_sc_hd__decap_3
XFILLER_72_414 VGND VGND VPWR VPWR sky130_fd_sc_hd__decap_3
XFILLER_84_296 VGND VGND VPWR VPWR sky130_fd_sc_hd__decap_3
XFILLER_25_330 VGND VGND VPWR VPWR sky130_fd_sc_hd__decap_3
XFILLER_53_650 VGND VGND VPWR VPWR sky130_fd_sc_hd__decap_3
XFILLER_111_42 VGND VGND VPWR VPWR sky130_fd_sc_hd__decap_3
XFILLER_13_525 VGND VGND VPWR VPWR sky130_fd_sc_hd__fill_1
XFILLER_25_363 VGND VGND VPWR VPWR sky130_fd_sc_hd__decap_3
XFILLER_52_171 VGND VGND VPWR VPWR sky130_fd_sc_hd__fill_2
XFILLER_53_694 VGND VGND VPWR VPWR sky130_fd_sc_hd__decap_3
XFILLER_111_75 VGND VGND VPWR VPWR sky130_fd_sc_hd__decap_3
XFILLER_111_97 VGND VGND VPWR VPWR sky130_fd_sc_hd__fill_1
XFILLER_13_547 VGND VGND VPWR VPWR sky130_fd_sc_hd__decap_3
XFILLER_52_193 VGND VGND VPWR VPWR sky130_fd_sc_hd__decap_3
XFILLER_71_57 VGND VGND VPWR VPWR sky130_fd_sc_hd__decap_3
XTAP_TAPCELL_ROW_23_542 VGND VPWR sky130_fd_sc_hd__tapvpwrvgnd_1
XFILLER_21_591 VGND VGND VPWR VPWR sky130_fd_sc_hd__decap_3
XTAP_TAPCELL_ROW_51_895 VGND VPWR sky130_fd_sc_hd__tapvpwrvgnd_1
XFILLER_107_641 VGND VGND VPWR VPWR sky130_fd_sc_hd__decap_3
XFILLER_4_256 VGND VGND VPWR VPWR sky130_fd_sc_hd__decap_3
XFILLER_107_685 VGND VGND VPWR VPWR sky130_fd_sc_hd__decap_3
XFILLER_67_219 VGND VGND VPWR VPWR sky130_fd_sc_hd__decap_3
XFILLER_95_517 VGND VGND VPWR VPWR sky130_fd_sc_hd__decap_3
XFILLER_36_628 VGND VGND VPWR VPWR sky130_fd_sc_hd__decap_3
XFILLER_48_477 VGND VGND VPWR VPWR sky130_fd_sc_hd__fill_2
XFILLER_75_252 VGND VGND VPWR VPWR sky130_fd_sc_hd__decap_3
XFILLER_91_712 VGND VGND VPWR VPWR sky130_fd_sc_hd__fill_2
XFILLER_29_691 VGND VGND VPWR VPWR sky130_fd_sc_hd__decap_3
XFILLER_63_425 VGND VGND VPWR VPWR sky130_fd_sc_hd__decap_3
XFILLER_63_447 VGND VGND VPWR VPWR sky130_fd_sc_hd__fill_1
XFILLER_75_274 VGND VGND VPWR VPWR sky130_fd_sc_hd__fill_2
Xplace403 _4337_/B VGND VGND VPWR VPWR _4416_/A2 sky130_fd_sc_hd__buf_2
XTAP_TAPCELL_ROW_59_995 VGND VPWR sky130_fd_sc_hd__tapvpwrvgnd_1
XFILLER_63_458 VGND VGND VPWR VPWR sky130_fd_sc_hd__fill_2
XFILLER_63_469 VGND VGND VPWR VPWR sky130_fd_sc_hd__fill_1
Xplace447 _7412_/A VGND VGND VPWR VPWR _5360_/S sky130_fd_sc_hd__buf_2
Xplace436 _4348_/B1 VGND VGND VPWR VPWR _4263_/A2 sky130_fd_sc_hd__buf_2
Xplace425 _3509_/B VGND VGND VPWR VPWR _4791_/C1 sky130_fd_sc_hd__buf_2
Xplace414 _4335_/A2 VGND VGND VPWR VPWR _5080_/S sky130_fd_sc_hd__buf_2
XFILLER_43_160 VGND VGND VPWR VPWR sky130_fd_sc_hd__decap_3
XFILLER_44_672 VGND VGND VPWR VPWR sky130_fd_sc_hd__decap_3
XFILLER_90_277 VGND VGND VPWR VPWR sky130_fd_sc_hd__decap_3
Xplace469 _4261_/A2 VGND VGND VPWR VPWR _4346_/B1 sky130_fd_sc_hd__buf_2
Xplace458 _4285_/A2 VGND VGND VPWR VPWR _4532_/S sky130_fd_sc_hd__buf_2
XFILLER_43_193 VGND VGND VPWR VPWR sky130_fd_sc_hd__decap_3
XFILLER_31_366 VGND VGND VPWR VPWR sky130_fd_sc_hd__decap_3
XFILLER_8_551 VGND VGND VPWR VPWR sky130_fd_sc_hd__decap_3
XANTENNA_1 _5198_/B VGND VGND VPWR VPWR sky130_fd_sc_hd__diode_2
XFILLER_8_584 VGND VGND VPWR VPWR sky130_fd_sc_hd__decap_3
XFILLER_8_595 VGND VGND VPWR VPWR sky130_fd_sc_hd__decap_3
X_4431_ _7271_/Q _4437_/A2 _4428_/X _4430_/X VGND VGND VPWR VPWR _4431_/X sky130_fd_sc_hd__a211o_2
XFILLER_113_600 VGND VGND VPWR VPWR sky130_fd_sc_hd__decap_3
X_7150_ _7374_/CLK _7150_/D _6430_/Y VGND VGND VPWR VPWR _7150_/Q sky130_fd_sc_hd__dfrtp_2
X_4362_ _4362_/A _4362_/B _4362_/C VGND VGND VPWR VPWR _4362_/X sky130_fd_sc_hd__and3_2
XFILLER_113_644 VGND VGND VPWR VPWR sky130_fd_sc_hd__decap_3
XFILLER_59_709 VGND VGND VPWR VPWR sky130_fd_sc_hd__decap_3
XFILLER_86_506 VGND VGND VPWR VPWR sky130_fd_sc_hd__decap_3
X_7081_ _7086_/CLK _7081_/D _6361_/Y VGND VGND VPWR VPWR _7081_/Q sky130_fd_sc_hd__dfrtp_2
X_4293_ _4612_/A _4612_/B VGND VGND VPWR VPWR _4293_/X sky130_fd_sc_hd__and2b_2
X_3313_ _3561_/B _6980_/Q _3324_/A _6982_/Q VGND VGND VPWR VPWR _4467_/B sky130_fd_sc_hd__nand4b_4
XFILLER_112_154 VGND VGND VPWR VPWR sky130_fd_sc_hd__decap_3
XFILLER_113_688 VGND VGND VPWR VPWR sky130_fd_sc_hd__decap_3
XFILLER_86_539 VGND VGND VPWR VPWR sky130_fd_sc_hd__decap_3
XFILLER_98_388 VGND VGND VPWR VPWR sky130_fd_sc_hd__decap_3
XFILLER_39_433 VGND VGND VPWR VPWR sky130_fd_sc_hd__fill_1
XFILLER_27_606 VGND VGND VPWR VPWR sky130_fd_sc_hd__decap_3
XFILLER_27_617 VGND VGND VPWR VPWR sky130_fd_sc_hd__decap_3
XFILLER_66_230 VGND VGND VPWR VPWR sky130_fd_sc_hd__decap_3
XFILLER_66_263 VGND VGND VPWR VPWR sky130_fd_sc_hd__decap_3
XFILLER_82_701 VGND VGND VPWR VPWR sky130_fd_sc_hd__decap_3
XFILLER_54_414 VGND VGND VPWR VPWR sky130_fd_sc_hd__decap_3
XFILLER_81_200 VGND VGND VPWR VPWR sky130_fd_sc_hd__fill_2
XFILLER_35_650 VGND VGND VPWR VPWR sky130_fd_sc_hd__decap_3
XFILLER_42_609 VGND VGND VPWR VPWR sky130_fd_sc_hd__decap_3
X_6934_ _6943_/CLK _6934_/D VGND VGND VPWR VPWR _6934_/Q sky130_fd_sc_hd__dfxtp_2
XFILLER_22_300 VGND VGND VPWR VPWR sky130_fd_sc_hd__decap_3
XFILLER_35_694 VGND VGND VPWR VPWR sky130_fd_sc_hd__decap_3
XFILLER_50_620 VGND VGND VPWR VPWR sky130_fd_sc_hd__decap_3
XFILLER_62_480 VGND VGND VPWR VPWR sky130_fd_sc_hd__decap_3
X_6865_ _6944_/CLK _6865_/D VGND VGND VPWR VPWR _6865_/Q sky130_fd_sc_hd__dfxtp_2
XFILLER_22_355 VGND VGND VPWR VPWR sky130_fd_sc_hd__decap_3
XFILLER_50_675 VGND VGND VPWR VPWR sky130_fd_sc_hd__decap_3
X_6796_ _6944_/CLK _6796_/D VGND VGND VPWR VPWR _6796_/Q sky130_fd_sc_hd__dfxtp_2
XTAP_TAPCELL_ROW_20_512 VGND VPWR sky130_fd_sc_hd__tapvpwrvgnd_1
XFILLER_108_416 VGND VGND VPWR VPWR sky130_fd_sc_hd__decap_3
X_5678_ _7345_/Q _5678_/A1 _5721_/S VGND VGND VPWR VPWR _6689_/D sky130_fd_sc_hd__mux2_2
X_4629_ _4629_/A _4629_/B VGND VGND VPWR VPWR _4629_/Y sky130_fd_sc_hd__nor2_2
XFILLER_104_622 VGND VGND VPWR VPWR sky130_fd_sc_hd__decap_3
XFILLER_89_322 VGND VGND VPWR VPWR sky130_fd_sc_hd__decap_3
X_7348_ _7350_/CLK _7348_/D _6628_/Y VGND VGND VPWR VPWR _7348_/Q sky130_fd_sc_hd__dfrtp_2
XFILLER_104_666 VGND VGND VPWR VPWR sky130_fd_sc_hd__decap_3
XFILLER_106_20 VGND VGND VPWR VPWR sky130_fd_sc_hd__decap_3
X_7279_ _7349_/CLK _7279_/D _6559_/Y VGND VGND VPWR VPWR _7279_/Q sky130_fd_sc_hd__dfrtp_2
XFILLER_103_143 VGND VGND VPWR VPWR sky130_fd_sc_hd__decap_3
XFILLER_104_699 VGND VGND VPWR VPWR sky130_fd_sc_hd__fill_1
XFILLER_49_219 VGND VGND VPWR VPWR sky130_fd_sc_hd__decap_3
XFILLER_103_198 VGND VGND VPWR VPWR sky130_fd_sc_hd__fill_1
XFILLER_66_35 VGND VGND VPWR VPWR sky130_fd_sc_hd__decap_3
XFILLER_45_403 VGND VGND VPWR VPWR sky130_fd_sc_hd__fill_2
XFILLER_73_712 VGND VGND VPWR VPWR sky130_fd_sc_hd__fill_2
Xhold1240 _7178_/Q VGND VGND VPWR VPWR _5304_/A0 sky130_fd_sc_hd__dlygate4sd3_1
Xhold1251 _7317_/Q VGND VGND VPWR VPWR _4524_/A0 sky130_fd_sc_hd__dlygate4sd3_1
XFILLER_18_628 VGND VGND VPWR VPWR sky130_fd_sc_hd__decap_3
XFILLER_72_200 VGND VGND VPWR VPWR sky130_fd_sc_hd__decap_3
XFILLER_72_222 VGND VGND VPWR VPWR sky130_fd_sc_hd__decap_3
Xhold1262 _7252_/Q VGND VGND VPWR VPWR _5132_/A0 sky130_fd_sc_hd__dlygate4sd3_1
Xhold1273 _7165_/Q VGND VGND VPWR VPWR _5331_/A0 sky130_fd_sc_hd__dlygate4sd3_1
Xhold1284 _7314_/Q VGND VGND VPWR VPWR _4530_/A0 sky130_fd_sc_hd__dlygate4sd3_1
XTAP_TAPCELL_ROW_86_1337 VGND VPWR sky130_fd_sc_hd__tapvpwrvgnd_1
XTAP_TAPCELL_ROW_28_612 VGND VPWR sky130_fd_sc_hd__tapvpwrvgnd_1
XFILLER_33_609 VGND VGND VPWR VPWR sky130_fd_sc_hd__decap_3
XFILLER_45_469 VGND VGND VPWR VPWR sky130_fd_sc_hd__decap_3
XFILLER_72_244 VGND VGND VPWR VPWR sky130_fd_sc_hd__decap_3
XFILLER_82_23 VGND VGND VPWR VPWR sky130_fd_sc_hd__decap_3
Xhold1295 _7175_/Q VGND VGND VPWR VPWR _5310_/A0 sky130_fd_sc_hd__dlygate4sd3_1
XTAP_TAPCELL_ROW_56_954 VGND VPWR sky130_fd_sc_hd__tapvpwrvgnd_1
XFILLER_26_672 VGND VGND VPWR VPWR sky130_fd_sc_hd__decap_3
XFILLER_32_119 VGND VGND VPWR VPWR sky130_fd_sc_hd__decap_3
XFILLER_60_417 VGND VGND VPWR VPWR sky130_fd_sc_hd__decap_3
XFILLER_72_288 VGND VGND VPWR VPWR sky130_fd_sc_hd__decap_3
XFILLER_13_322 VGND VGND VPWR VPWR sky130_fd_sc_hd__decap_3
XFILLER_25_182 VGND VGND VPWR VPWR sky130_fd_sc_hd__decap_3
XFILLER_41_620 VGND VGND VPWR VPWR sky130_fd_sc_hd__decap_3
XFILLER_72_299 VGND VGND VPWR VPWR sky130_fd_sc_hd__decap_3
XFILLER_82_67 VGND VGND VPWR VPWR sky130_fd_sc_hd__decap_3
XFILLER_13_355 VGND VGND VPWR VPWR sky130_fd_sc_hd__decap_3
XFILLER_41_653 VGND VGND VPWR VPWR sky130_fd_sc_hd__decap_3
XFILLER_13_399 VGND VGND VPWR VPWR sky130_fd_sc_hd__decap_3
XFILLER_41_697 VGND VGND VPWR VPWR sky130_fd_sc_hd__decap_3
XFILLER_9_326 VGND VGND VPWR VPWR sky130_fd_sc_hd__decap_3
XTAP_TAPCELL_ROW_97_1466 VGND VPWR sky130_fd_sc_hd__tapvpwrvgnd_1
XFILLER_5_554 VGND VGND VPWR VPWR sky130_fd_sc_hd__decap_3
XFILLER_107_482 VGND VGND VPWR VPWR sky130_fd_sc_hd__decap_3
XFILLER_5_576 VGND VGND VPWR VPWR sky130_fd_sc_hd__decap_3
XFILLER_99_119 VGND VGND VPWR VPWR sky130_fd_sc_hd__decap_3
XFILLER_110_625 VGND VGND VPWR VPWR sky130_fd_sc_hd__decap_3
XFILLER_95_314 VGND VGND VPWR VPWR sky130_fd_sc_hd__decap_3
XFILLER_0_270 VGND VGND VPWR VPWR sky130_fd_sc_hd__fill_2
XFILLER_0_281 VGND VGND VPWR VPWR sky130_fd_sc_hd__decap_3
XFILLER_110_669 VGND VGND VPWR VPWR sky130_fd_sc_hd__decap_3
XFILLER_64_701 VGND VGND VPWR VPWR sky130_fd_sc_hd__decap_3
XFILLER_48_274 VGND VGND VPWR VPWR sky130_fd_sc_hd__decap_3
XFILLER_76_583 VGND VGND VPWR VPWR sky130_fd_sc_hd__fill_2
XFILLER_91_520 VGND VGND VPWR VPWR sky130_fd_sc_hd__decap_3
XFILLER_17_650 VGND VGND VPWR VPWR sky130_fd_sc_hd__decap_3
XFILLER_36_469 VGND VGND VPWR VPWR sky130_fd_sc_hd__decap_3
XFILLER_63_222 VGND VGND VPWR VPWR sky130_fd_sc_hd__fill_2
XFILLER_91_564 VGND VGND VPWR VPWR sky130_fd_sc_hd__decap_3
XFILLER_91_586 VGND VGND VPWR VPWR sky130_fd_sc_hd__decap_3
XFILLER_16_193 VGND VGND VPWR VPWR sky130_fd_sc_hd__decap_3
XFILLER_17_694 VGND VGND VPWR VPWR sky130_fd_sc_hd__decap_3
XFILLER_32_631 VGND VGND VPWR VPWR sky130_fd_sc_hd__decap_3
X_3931_ _7374_/Q _4474_/A0 _3954_/S VGND VGND VPWR VPWR _7374_/D sky130_fd_sc_hd__mux2_2
XTAP_TAPCELL_ROW_106_1584 VGND VPWR sky130_fd_sc_hd__tapvpwrvgnd_1
XFILLER_31_152 VGND VGND VPWR VPWR sky130_fd_sc_hd__decap_3
XFILLER_32_675 VGND VGND VPWR VPWR sky130_fd_sc_hd__decap_3
X_6650_ _6650_/A VGND VGND VPWR VPWR _6650_/Y sky130_fd_sc_hd__inv_2
X_3862_ _6923_/Q _3921_/A2 _3922_/A2 _6787_/Q VGND VGND VPWR VPWR _3862_/X sky130_fd_sc_hd__a22o_2
X_6581_ _6584_/A VGND VGND VPWR VPWR _6581_/Y sky130_fd_sc_hd__inv_2
XFILLER_31_196 VGND VGND VPWR VPWR sky130_fd_sc_hd__fill_2
X_3793_ _6756_/Q _3893_/B1 _3883_/B1 _6768_/Q VGND VGND VPWR VPWR _3793_/X sky130_fd_sc_hd__a22o_2
XFILLER_117_213 VGND VGND VPWR VPWR sky130_fd_sc_hd__fill_2
Xoutput601 _5117_/B VGND VGND VPWR VPWR alu_result_out[7] sky130_fd_sc_hd__clkdlybuf4s25_1
X_7202_ _7400_/CLK _7202_/D _6482_/Y VGND VGND VPWR VPWR _7202_/Q sky130_fd_sc_hd__dfrtp_2
Xoutput645 _6999_/Q VGND VGND VPWR VPWR pc_out[22] sky130_fd_sc_hd__clkdlybuf4s25_1
Xoutput634 _6989_/Q VGND VGND VPWR VPWR pc_out[12] sky130_fd_sc_hd__clkdlybuf4s25_1
Xoutput623 _7412_/X VGND VGND VPWR VPWR instruction_out[30] sky130_fd_sc_hd__clkdlybuf4s25_1
Xoutput612 _5161_/A VGND VGND VPWR VPWR instruction_out[18] sky130_fd_sc_hd__clkdlybuf4s25_1
X_5394_ _5394_/A0 _4964_/X _5402_/S VGND VGND VPWR VPWR _7136_/D sky130_fd_sc_hd__mux2_2
X_4414_ _7240_/Q _4433_/B _3952_/S _7208_/Q VGND VGND VPWR VPWR _4414_/X sky130_fd_sc_hd__a22o_2
XFILLER_99_620 VGND VGND VPWR VPWR sky130_fd_sc_hd__decap_3
X_7133_ _7357_/CLK _7133_/D _6413_/Y VGND VGND VPWR VPWR _7133_/Q sky130_fd_sc_hd__dfrtp_2
Xoutput656 _6980_/Q VGND VGND VPWR VPWR pc_out[3] sky130_fd_sc_hd__clkdlybuf4s25_1
X_4345_ _4343_/X _4345_/B VGND VGND VPWR VPWR _5101_/B sky130_fd_sc_hd__nand2b_2
XFILLER_99_653 VGND VGND VPWR VPWR sky130_fd_sc_hd__decap_3
XFILLER_113_452 VGND VGND VPWR VPWR sky130_fd_sc_hd__fill_2
XFILLER_59_517 VGND VGND VPWR VPWR sky130_fd_sc_hd__decap_3
XFILLER_86_303 VGND VGND VPWR VPWR sky130_fd_sc_hd__decap_3
XTAP_TAPCELL_ROW_70_1138 VGND VPWR sky130_fd_sc_hd__tapvpwrvgnd_1
XTAP_TAPCELL_ROW_70_1127 VGND VPWR sky130_fd_sc_hd__tapvpwrvgnd_1
XTAP_TAPCELL_ROW_6_329 VGND VPWR sky130_fd_sc_hd__tapvpwrvgnd_1
XFILLER_99_697 VGND VGND VPWR VPWR sky130_fd_sc_hd__decap_3
XFILLER_101_647 VGND VGND VPWR VPWR sky130_fd_sc_hd__decap_3
XFILLER_98_185 VGND VGND VPWR VPWR sky130_fd_sc_hd__decap_3
X_7064_ _7390_/CLK _7064_/D _6344_/Y VGND VGND VPWR VPWR _7064_/Q sky130_fd_sc_hd__dfrtp_2
XFILLER_100_168 VGND VGND VPWR VPWR sky130_fd_sc_hd__decap_3
XFILLER_39_252 VGND VGND VPWR VPWR sky130_fd_sc_hd__decap_3
XFILLER_36_27 VGND VGND VPWR VPWR sky130_fd_sc_hd__fill_1
XFILLER_54_200 VGND VGND VPWR VPWR sky130_fd_sc_hd__decap_3
XFILLER_55_712 VGND VGND VPWR VPWR sky130_fd_sc_hd__fill_2
XFILLER_67_572 VGND VGND VPWR VPWR sky130_fd_sc_hd__fill_2
XFILLER_27_447 VGND VGND VPWR VPWR sky130_fd_sc_hd__fill_1
XFILLER_39_296 VGND VGND VPWR VPWR sky130_fd_sc_hd__decap_3
XFILLER_54_244 VGND VGND VPWR VPWR sky130_fd_sc_hd__decap_3
XFILLER_70_704 VGND VGND VPWR VPWR sky130_fd_sc_hd__decap_3
XFILLER_82_531 VGND VGND VPWR VPWR sky130_fd_sc_hd__fill_1
XFILLER_54_277 VGND VGND VPWR VPWR sky130_fd_sc_hd__fill_1
XTAP_TAPCELL_ROW_53_924 VGND VPWR sky130_fd_sc_hd__tapvpwrvgnd_1
XFILLER_23_620 VGND VGND VPWR VPWR sky130_fd_sc_hd__decap_3
X_6917_ clkload8/A _6917_/D VGND VGND VPWR VPWR _6917_/Q sky130_fd_sc_hd__dfxtp_2
XFILLER_22_141 VGND VGND VPWR VPWR sky130_fd_sc_hd__decap_3
XFILLER_23_653 VGND VGND VPWR VPWR sky130_fd_sc_hd__decap_3
XFILLER_50_450 VGND VGND VPWR VPWR sky130_fd_sc_hd__decap_3
XFILLER_50_461 VGND VGND VPWR VPWR sky130_fd_sc_hd__decap_3
XFILLER_52_48 VGND VGND VPWR VPWR sky130_fd_sc_hd__fill_2
X_6848_ _7189_/CLK _6848_/D VGND VGND VPWR VPWR _6848_/Q sky130_fd_sc_hd__dfxtp_2
XTAP_TAPCELL_ROW_81_1267 VGND VPWR sky130_fd_sc_hd__tapvpwrvgnd_1
XFILLER_22_174 VGND VGND VPWR VPWR sky130_fd_sc_hd__decap_3
XFILLER_22_185 VGND VGND VPWR VPWR sky130_fd_sc_hd__decap_3
XFILLER_23_697 VGND VGND VPWR VPWR sky130_fd_sc_hd__decap_3
XTAP_TAPCELL_ROW_33_670 VGND VPWR sky130_fd_sc_hd__tapvpwrvgnd_1
XFILLER_109_703 VGND VGND VPWR VPWR sky130_fd_sc_hd__decap_3
XFILLER_10_358 VGND VGND VPWR VPWR sky130_fd_sc_hd__decap_3
X_6779_ _6923_/CLK _6779_/D VGND VGND VPWR VPWR _6779_/Q sky130_fd_sc_hd__dfxtp_2
XFILLER_108_224 VGND VGND VPWR VPWR sky130_fd_sc_hd__decap_3
XFILLER_6_318 VGND VGND VPWR VPWR sky130_fd_sc_hd__decap_3
XFILLER_108_268 VGND VGND VPWR VPWR sky130_fd_sc_hd__decap_3
XFILLER_2_513 VGND VGND VPWR VPWR sky130_fd_sc_hd__decap_3
XFILLER_104_430 VGND VGND VPWR VPWR sky130_fd_sc_hd__fill_2
XFILLER_104_441 VGND VGND VPWR VPWR sky130_fd_sc_hd__decap_3
XFILLER_117_41 VGND VGND VPWR VPWR sky130_fd_sc_hd__decap_3
XFILLER_117_63 VGND VGND VPWR VPWR sky130_fd_sc_hd__decap_3
XFILLER_2_557 VGND VGND VPWR VPWR sky130_fd_sc_hd__decap_3
XFILLER_104_474 VGND VGND VPWR VPWR sky130_fd_sc_hd__fill_2
XFILLER_117_96 VGND VGND VPWR VPWR sky130_fd_sc_hd__decap_3
XFILLER_77_325 VGND VGND VPWR VPWR sky130_fd_sc_hd__fill_1
XFILLER_89_196 VGND VGND VPWR VPWR sky130_fd_sc_hd__decap_3
XFILLER_46_701 VGND VGND VPWR VPWR sky130_fd_sc_hd__decap_3
XFILLER_77_358 VGND VGND VPWR VPWR sky130_fd_sc_hd__decap_3
XFILLER_45_200 VGND VGND VPWR VPWR sky130_fd_sc_hd__decap_3
XFILLER_73_520 VGND VGND VPWR VPWR sky130_fd_sc_hd__decap_3
XFILLER_18_447 VGND VGND VPWR VPWR sky130_fd_sc_hd__decap_3
XFILLER_45_244 VGND VGND VPWR VPWR sky130_fd_sc_hd__decap_3
XFILLER_85_391 VGND VGND VPWR VPWR sky130_fd_sc_hd__fill_1
Xhold1070 _7399_/Q VGND VGND VPWR VPWR _3710_/A1 sky130_fd_sc_hd__dlygate4sd3_1
Xhold1081 _7198_/Q VGND VGND VPWR VPWR _5264_/A0 sky130_fd_sc_hd__dlygate4sd3_1
Xhold1092 _7277_/Q VGND VGND VPWR VPWR _4735_/A0 sky130_fd_sc_hd__dlygate4sd3_1
XFILLER_60_203 VGND VGND VPWR VPWR sky130_fd_sc_hd__fill_2
XFILLER_93_99 VGND VGND VPWR VPWR sky130_fd_sc_hd__decap_3
XFILLER_14_631 VGND VGND VPWR VPWR sky130_fd_sc_hd__decap_3
XFILLER_26_480 VGND VGND VPWR VPWR sky130_fd_sc_hd__decap_3
XFILLER_45_288 VGND VGND VPWR VPWR sky130_fd_sc_hd__decap_3
XFILLER_13_130 VGND VGND VPWR VPWR sky130_fd_sc_hd__decap_3
XFILLER_14_675 VGND VGND VPWR VPWR sky130_fd_sc_hd__decap_3
XFILLER_60_269 VGND VGND VPWR VPWR sky130_fd_sc_hd__fill_1
XFILLER_41_461 VGND VGND VPWR VPWR sky130_fd_sc_hd__decap_3
XFILLER_9_167 VGND VGND VPWR VPWR sky130_fd_sc_hd__fill_1
XFILLER_115_706 VGND VGND VPWR VPWR sky130_fd_sc_hd__decap_3
XFILLER_5_340 VGND VGND VPWR VPWR sky130_fd_sc_hd__decap_3
XTAP_TAPCELL_ROW_11_397 VGND VPWR sky130_fd_sc_hd__tapvpwrvgnd_1
XFILLER_54_6 VGND VGND VPWR VPWR sky130_fd_sc_hd__fill_2
XFILLER_5_373 VGND VGND VPWR VPWR sky130_fd_sc_hd__decap_3
XFILLER_107_290 VGND VGND VPWR VPWR sky130_fd_sc_hd__decap_3
XFILLER_114_238 VGND VGND VPWR VPWR sky130_fd_sc_hd__decap_3
XFILLER_3_20 VGND VGND VPWR VPWR sky130_fd_sc_hd__decap_3
X_4130_ _7235_/Q _4430_/A2 _4459_/C1 _7171_/Q _4129_/X VGND VGND VPWR VPWR _4130_/X
+ sky130_fd_sc_hd__a221o_2
XFILLER_110_411 VGND VGND VPWR VPWR sky130_fd_sc_hd__decap_3
XFILLER_95_111 VGND VGND VPWR VPWR sky130_fd_sc_hd__fill_1
XFILLER_95_122 VGND VGND VPWR VPWR sky130_fd_sc_hd__decap_3
XFILLER_96_634 VGND VGND VPWR VPWR sky130_fd_sc_hd__decap_3
XFILLER_96_645 VGND VGND VPWR VPWR sky130_fd_sc_hd__decap_3
XFILLER_110_466 VGND VGND VPWR VPWR sky130_fd_sc_hd__fill_1
XFILLER_3_75 VGND VGND VPWR VPWR sky130_fd_sc_hd__fill_2
XFILLER_49_550 VGND VGND VPWR VPWR sky130_fd_sc_hd__fill_1
XFILLER_49_561 VGND VGND VPWR VPWR sky130_fd_sc_hd__fill_1
XFILLER_56_509 VGND VGND VPWR VPWR sky130_fd_sc_hd__decap_3
XFILLER_95_155 VGND VGND VPWR VPWR sky130_fd_sc_hd__decap_3
XFILLER_95_166 VGND VGND VPWR VPWR sky130_fd_sc_hd__fill_2
XFILLER_96_678 VGND VGND VPWR VPWR sky130_fd_sc_hd__decap_3
X_4061_ _7244_/Q _4433_/B _4436_/B1 _7180_/Q VGND VGND VPWR VPWR _4061_/X sky130_fd_sc_hd__a22o_2
XFILLER_110_477 VGND VGND VPWR VPWR sky130_fd_sc_hd__fill_2
XFILLER_36_200 VGND VGND VPWR VPWR sky130_fd_sc_hd__decap_3
XFILLER_37_712 VGND VGND VPWR VPWR sky130_fd_sc_hd__fill_2
XTAP_TAPCELL_ROW_108_1613 VGND VPWR sky130_fd_sc_hd__tapvpwrvgnd_1
XTAP_TAPCELL_ROW_108_1602 VGND VPWR sky130_fd_sc_hd__tapvpwrvgnd_1
XFILLER_64_531 VGND VGND VPWR VPWR sky130_fd_sc_hd__fill_1
XFILLER_52_704 VGND VGND VPWR VPWR sky130_fd_sc_hd__decap_3
XFILLER_91_372 VGND VGND VPWR VPWR sky130_fd_sc_hd__decap_3
XFILLER_36_288 VGND VGND VPWR VPWR sky130_fd_sc_hd__decap_3
XFILLER_51_214 VGND VGND VPWR VPWR sky130_fd_sc_hd__fill_2
XFILLER_51_225 VGND VGND VPWR VPWR sky130_fd_sc_hd__fill_1
X_4963_ _4963_/A _4963_/B VGND VGND VPWR VPWR _6994_/D sky130_fd_sc_hd__nor2_2
XTAP_TAPCELL_ROW_19_497 VGND VPWR sky130_fd_sc_hd__tapvpwrvgnd_1
XFILLER_51_258 VGND VGND VPWR VPWR sky130_fd_sc_hd__decap_3
X_6702_ _6944_/CLK _6702_/D VGND VGND VPWR VPWR _6702_/Q sky130_fd_sc_hd__dfxtp_2
X_3914_ _3629_/A _3911_/X _3913_/X _3714_/X VGND VGND VPWR VPWR _3914_/X sky130_fd_sc_hd__a22o_2
XFILLER_20_601 VGND VGND VPWR VPWR sky130_fd_sc_hd__decap_3
XFILLER_20_634 VGND VGND VPWR VPWR sky130_fd_sc_hd__decap_3
XFILLER_32_472 VGND VGND VPWR VPWR sky130_fd_sc_hd__decap_3
X_6633_ _6640_/A VGND VGND VPWR VPWR _6633_/Y sky130_fd_sc_hd__inv_2
X_4894_ _4908_/A _4908_/B VGND VGND VPWR VPWR _4909_/B sky130_fd_sc_hd__and2_2
XFILLER_118_500 VGND VGND VPWR VPWR sky130_fd_sc_hd__fill_1
XFILLER_20_645 VGND VGND VPWR VPWR sky130_fd_sc_hd__decap_3
X_3845_ _3845_/A _3845_/B VGND VGND VPWR VPWR _3845_/X sky130_fd_sc_hd__or2_2
XFILLER_118_522 VGND VGND VPWR VPWR sky130_fd_sc_hd__decap_3
XFILLER_118_533 VGND VGND VPWR VPWR sky130_fd_sc_hd__decap_3
XFILLER_20_678 VGND VGND VPWR VPWR sky130_fd_sc_hd__decap_3
X_6564_ _6593_/A VGND VGND VPWR VPWR _6564_/Y sky130_fd_sc_hd__inv_2
X_3776_ _6727_/Q _3851_/A2 _3853_/A2 _6977_/Q VGND VGND VPWR VPWR _3776_/X sky130_fd_sc_hd__a22o_2
XTAP_TAPCELL_ROW_119_1753 VGND VPWR sky130_fd_sc_hd__tapvpwrvgnd_1
XTAP_TAPCELL_ROW_119_1742 VGND VPWR sky130_fd_sc_hd__tapvpwrvgnd_1
X_6495_ _6664_/A VGND VGND VPWR VPWR _6495_/Y sky130_fd_sc_hd__inv_2
XTAP_TAPCELL_ROW_119_1764 VGND VPWR sky130_fd_sc_hd__tapvpwrvgnd_1
X_5377_ _5377_/A0 _4822_/X _5390_/S VGND VGND VPWR VPWR _7144_/D sky130_fd_sc_hd__mux2_2
XFILLER_99_461 VGND VGND VPWR VPWR sky130_fd_sc_hd__decap_3
XFILLER_86_100 VGND VGND VPWR VPWR sky130_fd_sc_hd__decap_3
XFILLER_87_634 VGND VGND VPWR VPWR sky130_fd_sc_hd__decap_3
X_7116_ _7372_/CLK _7116_/D _6396_/Y VGND VGND VPWR VPWR _7116_/Q sky130_fd_sc_hd__dfrtp_2
X_4328_ _4362_/A _4362_/B _4362_/C VGND VGND VPWR VPWR _5057_/B sky130_fd_sc_hd__a21boi_2
XFILLER_59_358 VGND VGND VPWR VPWR sky130_fd_sc_hd__decap_3
XFILLER_86_144 VGND VGND VPWR VPWR sky130_fd_sc_hd__decap_3
XFILLER_87_667 VGND VGND VPWR VPWR sky130_fd_sc_hd__decap_3
X_7047_ _7403_/CLK _7047_/D _6327_/Y VGND VGND VPWR VPWR _7047_/Q sky130_fd_sc_hd__dfrtp_2
XFILLER_101_488 VGND VGND VPWR VPWR sky130_fd_sc_hd__decap_3
XFILLER_28_701 VGND VGND VPWR VPWR sky130_fd_sc_hd__decap_3
XFILLER_86_177 VGND VGND VPWR VPWR sky130_fd_sc_hd__decap_3
XFILLER_27_222 VGND VGND VPWR VPWR sky130_fd_sc_hd__fill_2
XFILLER_55_520 VGND VGND VPWR VPWR sky130_fd_sc_hd__fill_1
XFILLER_55_542 VGND VGND VPWR VPWR sky130_fd_sc_hd__fill_1
XFILLER_27_255 VGND VGND VPWR VPWR sky130_fd_sc_hd__fill_2
XFILLER_42_203 VGND VGND VPWR VPWR sky130_fd_sc_hd__decap_3
XFILLER_55_564 VGND VGND VPWR VPWR sky130_fd_sc_hd__decap_3
XFILLER_55_586 VGND VGND VPWR VPWR sky130_fd_sc_hd__decap_3
XFILLER_82_361 VGND VGND VPWR VPWR sky130_fd_sc_hd__decap_3
XFILLER_15_428 VGND VGND VPWR VPWR sky130_fd_sc_hd__decap_3
XFILLER_63_36 VGND VGND VPWR VPWR sky130_fd_sc_hd__fill_1
XFILLER_70_523 VGND VGND VPWR VPWR sky130_fd_sc_hd__decap_3
XFILLER_82_383 VGND VGND VPWR VPWR sky130_fd_sc_hd__decap_3
XFILLER_82_394 VGND VGND VPWR VPWR sky130_fd_sc_hd__decap_3
XFILLER_42_247 VGND VGND VPWR VPWR sky130_fd_sc_hd__decap_3
XFILLER_11_612 VGND VGND VPWR VPWR sky130_fd_sc_hd__decap_3
XFILLER_11_623 VGND VGND VPWR VPWR sky130_fd_sc_hd__decap_3
XFILLER_23_472 VGND VGND VPWR VPWR sky130_fd_sc_hd__decap_3
XFILLER_70_589 VGND VGND VPWR VPWR sky130_fd_sc_hd__decap_3
XFILLER_10_111 VGND VGND VPWR VPWR sky130_fd_sc_hd__fill_2
XFILLER_11_656 VGND VGND VPWR VPWR sky130_fd_sc_hd__decap_3
XFILLER_109_500 VGND VGND VPWR VPWR sky130_fd_sc_hd__decap_3
XFILLER_10_166 VGND VGND VPWR VPWR sky130_fd_sc_hd__decap_3
XFILLER_7_638 VGND VGND VPWR VPWR sky130_fd_sc_hd__decap_3
XFILLER_6_159 VGND VGND VPWR VPWR sky130_fd_sc_hd__decap_3
XFILLER_109_599 VGND VGND VPWR VPWR sky130_fd_sc_hd__decap_3
XTAP_TAPCELL_ROW_94_1436 VGND VPWR sky130_fd_sc_hd__tapvpwrvgnd_1
XFILLER_2_332 VGND VGND VPWR VPWR sky130_fd_sc_hd__decap_3
XFILLER_88_55 VGND VGND VPWR VPWR sky130_fd_sc_hd__decap_3
XFILLER_88_88 VGND VGND VPWR VPWR sky130_fd_sc_hd__decap_3
XFILLER_97_409 VGND VGND VPWR VPWR sky130_fd_sc_hd__decap_3
XFILLER_104_271 VGND VGND VPWR VPWR sky130_fd_sc_hd__decap_3
XFILLER_77_100 VGND VGND VPWR VPWR sky130_fd_sc_hd__decap_3
XFILLER_77_122 VGND VGND VPWR VPWR sky130_fd_sc_hd__decap_3
XFILLER_78_623 VGND VGND VPWR VPWR sky130_fd_sc_hd__decap_3
XFILLER_78_645 VGND VGND VPWR VPWR sky130_fd_sc_hd__decap_3
XFILLER_77_144 VGND VGND VPWR VPWR sky130_fd_sc_hd__decap_3
XFILLER_78_678 VGND VGND VPWR VPWR sky130_fd_sc_hd__decap_3
XFILLER_18_200 VGND VGND VPWR VPWR sky130_fd_sc_hd__decap_3
XFILLER_19_712 VGND VGND VPWR VPWR sky130_fd_sc_hd__fill_2
XFILLER_77_166 VGND VGND VPWR VPWR sky130_fd_sc_hd__fill_2
XFILLER_92_103 VGND VGND VPWR VPWR sky130_fd_sc_hd__decap_3
XFILLER_93_626 VGND VGND VPWR VPWR sky130_fd_sc_hd__decap_3
XFILLER_18_233 VGND VGND VPWR VPWR sky130_fd_sc_hd__decap_3
XFILLER_46_531 VGND VGND VPWR VPWR sky130_fd_sc_hd__fill_1
XFILLER_58_380 VGND VGND VPWR VPWR sky130_fd_sc_hd__decap_3
XFILLER_92_136 VGND VGND VPWR VPWR sky130_fd_sc_hd__decap_3
XFILLER_92_147 VGND VGND VPWR VPWR sky130_fd_sc_hd__decap_3
XFILLER_93_659 VGND VGND VPWR VPWR sky130_fd_sc_hd__decap_3
XFILLER_34_704 VGND VGND VPWR VPWR sky130_fd_sc_hd__decap_3
XFILLER_80_309 VGND VGND VPWR VPWR sky130_fd_sc_hd__decap_3
XFILLER_18_299 VGND VGND VPWR VPWR sky130_fd_sc_hd__decap_3
XFILLER_33_225 VGND VGND VPWR VPWR sky130_fd_sc_hd__decap_3
XFILLER_61_534 VGND VGND VPWR VPWR sky130_fd_sc_hd__decap_3
XFILLER_73_383 VGND VGND VPWR VPWR sky130_fd_sc_hd__decap_3
XFILLER_21_409 VGND VGND VPWR VPWR sky130_fd_sc_hd__decap_3
XFILLER_61_567 VGND VGND VPWR VPWR sky130_fd_sc_hd__decap_3
XTAP_TAPCELL_ROW_16_456 VGND VPWR sky130_fd_sc_hd__tapvpwrvgnd_1
XTAP_TAPCELL_ROW_103_1543 VGND VPWR sky130_fd_sc_hd__tapvpwrvgnd_1
XFILLER_14_472 VGND VGND VPWR VPWR sky130_fd_sc_hd__decap_3
X_3630_ _3630_/A _3630_/B VGND VGND VPWR VPWR _3636_/B sky130_fd_sc_hd__and2_2
X_3561_ _5129_/A _3561_/B _5668_/A VGND VGND VPWR VPWR _3561_/X sky130_fd_sc_hd__or3_2
XFILLER_115_503 VGND VGND VPWR VPWR sky130_fd_sc_hd__fill_1
XFILLER_115_514 VGND VGND VPWR VPWR sky130_fd_sc_hd__decap_3
XFILLER_6_660 VGND VGND VPWR VPWR sky130_fd_sc_hd__decap_3
X_5300_ _5300_/A0 _4752_/X _5315_/S VGND VGND VPWR VPWR _7180_/D sky130_fd_sc_hd__mux2_2
XFILLER_115_536 VGND VGND VPWR VPWR sky130_fd_sc_hd__fill_2
XFILLER_6_693 VGND VGND VPWR VPWR sky130_fd_sc_hd__decap_3
X_6280_ _6621_/A VGND VGND VPWR VPWR _6280_/Y sky130_fd_sc_hd__inv_2
X_3492_ _7055_/Q _3558_/B _3487_/X _3491_/X VGND VGND VPWR VPWR _4460_/B sky130_fd_sc_hd__o22a_2
XFILLER_103_709 VGND VGND VPWR VPWR sky130_fd_sc_hd__decap_3
XFILLER_115_569 VGND VGND VPWR VPWR sky130_fd_sc_hd__decap_3
XTAP_TAPCELL_ROW_114_1683 VGND VPWR sky130_fd_sc_hd__tapvpwrvgnd_1
XFILLER_102_219 VGND VGND VPWR VPWR sky130_fd_sc_hd__decap_3
XFILLER_69_623 VGND VGND VPWR VPWR sky130_fd_sc_hd__decap_3
XFILLER_68_144 VGND VGND VPWR VPWR sky130_fd_sc_hd__decap_3
XFILLER_69_656 VGND VGND VPWR VPWR sky130_fd_sc_hd__decap_3
X_5093_ _5581_/S _3867_/X _5658_/C _5092_/X _3346_/A VGND VGND VPWR VPWR _5093_/X
+ sky130_fd_sc_hd__o32a_2
X_4113_ _7364_/Q _4338_/B1 _4112_/X _4248_/A VGND VGND VPWR VPWR _4113_/X sky130_fd_sc_hd__a211o_2
XFILLER_110_274 VGND VGND VPWR VPWR sky130_fd_sc_hd__decap_3
XFILLER_68_177 VGND VGND VPWR VPWR sky130_fd_sc_hd__decap_3
XFILLER_83_103 VGND VGND VPWR VPWR sky130_fd_sc_hd__decap_3
XFILLER_84_637 VGND VGND VPWR VPWR sky130_fd_sc_hd__decap_3
XFILLER_110_296 VGND VGND VPWR VPWR sky130_fd_sc_hd__decap_3
XFILLER_56_339 VGND VGND VPWR VPWR sky130_fd_sc_hd__decap_3
XFILLER_83_147 VGND VGND VPWR VPWR sky130_fd_sc_hd__decap_3
XFILLER_84_648 VGND VGND VPWR VPWR sky130_fd_sc_hd__decap_3
X_4044_ _7277_/Q _4131_/A2 _4041_/X _4043_/X VGND VGND VPWR VPWR _4044_/X sky130_fd_sc_hd__a211o_2
XFILLER_52_501 VGND VGND VPWR VPWR sky130_fd_sc_hd__decap_3
XFILLER_64_350 VGND VGND VPWR VPWR sky130_fd_sc_hd__decap_3
XFILLER_83_169 VGND VGND VPWR VPWR sky130_fd_sc_hd__decap_3
XFILLER_24_203 VGND VGND VPWR VPWR sky130_fd_sc_hd__decap_3
XFILLER_24_236 VGND VGND VPWR VPWR sky130_fd_sc_hd__decap_3
XFILLER_92_681 VGND VGND VPWR VPWR sky130_fd_sc_hd__decap_3
XFILLER_40_707 VGND VGND VPWR VPWR sky130_fd_sc_hd__decap_3
X_4946_ _4946_/A0 _4945_/X _4979_/S VGND VGND VPWR VPWR _7265_/D sky130_fd_sc_hd__mux2_2
XFILLER_32_280 VGND VGND VPWR VPWR sky130_fd_sc_hd__decap_3
X_4877_ _4799_/A _5663_/C _3753_/X _3346_/A VGND VGND VPWR VPWR _4877_/X sky130_fd_sc_hd__o211a_2
XFILLER_20_464 VGND VGND VPWR VPWR sky130_fd_sc_hd__decap_3
X_6616_ _6650_/A VGND VGND VPWR VPWR _6616_/Y sky130_fd_sc_hd__inv_2
X_3828_ _6926_/Q _3921_/A2 _3922_/A2 _6790_/Q _3827_/X VGND VGND VPWR VPWR _3828_/X
+ sky130_fd_sc_hd__a221o_2
XFILLER_118_341 VGND VGND VPWR VPWR sky130_fd_sc_hd__fill_2
X_6547_ _6650_/A VGND VGND VPWR VPWR _6547_/Y sky130_fd_sc_hd__inv_2
XFILLER_106_503 VGND VGND VPWR VPWR sky130_fd_sc_hd__decap_3
XFILLER_4_608 VGND VGND VPWR VPWR sky130_fd_sc_hd__decap_3
X_3759_ _6797_/Q _3759_/A2 _3767_/B1 _6885_/Q VGND VGND VPWR VPWR _3759_/X sky130_fd_sc_hd__a22o_2
XFILLER_106_536 VGND VGND VPWR VPWR sky130_fd_sc_hd__decap_3
X_6478_ _6672_/A VGND VGND VPWR VPWR _6478_/Y sky130_fd_sc_hd__inv_2
X_5429_ _7119_/Q _4470_/X _5429_/S VGND VGND VPWR VPWR _7119_/D sky130_fd_sc_hd__mux2_2
XFILLER_59_111 VGND VGND VPWR VPWR sky130_fd_sc_hd__fill_1
XFILLER_59_122 VGND VGND VPWR VPWR sky130_fd_sc_hd__decap_3
XFILLER_75_604 VGND VGND VPWR VPWR sky130_fd_sc_hd__decap_3
XFILLER_87_442 VGND VGND VPWR VPWR sky130_fd_sc_hd__decap_3
XFILLER_87_464 VGND VGND VPWR VPWR sky130_fd_sc_hd__decap_3
XFILLER_114_20 VGND VGND VPWR VPWR sky130_fd_sc_hd__decap_3
XFILLER_47_328 VGND VGND VPWR VPWR sky130_fd_sc_hd__decap_3
XFILLER_59_188 VGND VGND VPWR VPWR sky130_fd_sc_hd__fill_1
XFILLER_74_103 VGND VGND VPWR VPWR sky130_fd_sc_hd__decap_3
XFILLER_75_626 VGND VGND VPWR VPWR sky130_fd_sc_hd__decap_3
XFILLER_87_497 VGND VGND VPWR VPWR sky130_fd_sc_hd__decap_3
XFILLER_114_53 VGND VGND VPWR VPWR sky130_fd_sc_hd__decap_3
XFILLER_59_199 VGND VGND VPWR VPWR sky130_fd_sc_hd__decap_3
XFILLER_74_136 VGND VGND VPWR VPWR sky130_fd_sc_hd__decap_3
XFILLER_74_147 VGND VGND VPWR VPWR sky130_fd_sc_hd__decap_3
XFILLER_75_659 VGND VGND VPWR VPWR sky130_fd_sc_hd__decap_3
XFILLER_114_97 VGND VGND VPWR VPWR sky130_fd_sc_hd__decap_3
XFILLER_16_704 VGND VGND VPWR VPWR sky130_fd_sc_hd__decap_3
XFILLER_74_46 VGND VGND VPWR VPWR sky130_fd_sc_hd__decap_3
XFILLER_74_68 VGND VGND VPWR VPWR sky130_fd_sc_hd__decap_3
XFILLER_15_225 VGND VGND VPWR VPWR sky130_fd_sc_hd__decap_3
XFILLER_43_534 VGND VGND VPWR VPWR sky130_fd_sc_hd__decap_3
XFILLER_82_180 VGND VGND VPWR VPWR sky130_fd_sc_hd__decap_3
XFILLER_70_342 VGND VGND VPWR VPWR sky130_fd_sc_hd__decap_3
XFILLER_30_217 VGND VGND VPWR VPWR sky130_fd_sc_hd__decap_3
XTAP_TAPCELL_ROW_13_415 VGND VPWR sky130_fd_sc_hd__tapvpwrvgnd_1
XFILLER_11_442 VGND VGND VPWR VPWR sky130_fd_sc_hd__fill_2
XFILLER_90_67 VGND VGND VPWR VPWR sky130_fd_sc_hd__decap_3
XTAP_TAPCELL_ROW_13_426 VGND VPWR sky130_fd_sc_hd__tapvpwrvgnd_1
XTAP_TAPCELL_ROW_41_768 VGND VPWR sky130_fd_sc_hd__tapvpwrvgnd_1
XFILLER_7_446 VGND VGND VPWR VPWR sky130_fd_sc_hd__fill_2
XFILLER_99_54 VGND VGND VPWR VPWR sky130_fd_sc_hd__fill_2
XFILLER_109_396 VGND VGND VPWR VPWR sky130_fd_sc_hd__decap_3
XFILLER_99_98 VGND VGND VPWR VPWR sky130_fd_sc_hd__fill_2
XFILLER_112_517 VGND VGND VPWR VPWR sky130_fd_sc_hd__fill_1
XFILLER_3_641 VGND VGND VPWR VPWR sky130_fd_sc_hd__decap_3
XFILLER_98_707 VGND VGND VPWR VPWR sky130_fd_sc_hd__decap_3
XFILLER_3_685 VGND VGND VPWR VPWR sky130_fd_sc_hd__decap_3
XFILLER_97_228 VGND VGND VPWR VPWR sky130_fd_sc_hd__decap_3
XFILLER_66_626 VGND VGND VPWR VPWR sky130_fd_sc_hd__decap_3
XFILLER_38_339 VGND VGND VPWR VPWR sky130_fd_sc_hd__decap_3
XFILLER_65_125 VGND VGND VPWR VPWR sky130_fd_sc_hd__decap_3
XFILLER_66_648 VGND VGND VPWR VPWR sky130_fd_sc_hd__decap_3
XFILLER_46_361 VGND VGND VPWR VPWR sky130_fd_sc_hd__decap_3
XFILLER_65_158 VGND VGND VPWR VPWR sky130_fd_sc_hd__decap_3
XFILLER_65_169 VGND VGND VPWR VPWR sky130_fd_sc_hd__decap_3
XFILLER_80_106 VGND VGND VPWR VPWR sky130_fd_sc_hd__decap_3
XFILLER_81_629 VGND VGND VPWR VPWR sky130_fd_sc_hd__decap_3
XTAP_TAPCELL_ROW_49_868 VGND VPWR sky130_fd_sc_hd__tapvpwrvgnd_1
XFILLER_19_586 VGND VGND VPWR VPWR sky130_fd_sc_hd__decap_3
XFILLER_74_681 VGND VGND VPWR VPWR sky130_fd_sc_hd__decap_3
XFILLER_80_139 VGND VGND VPWR VPWR sky130_fd_sc_hd__fill_1
XFILLER_22_707 VGND VGND VPWR VPWR sky130_fd_sc_hd__decap_3
X_4800_ _7002_/Q _4826_/A _7003_/Q VGND VGND VPWR VPWR _4801_/B sky130_fd_sc_hd__a21oi_2
XFILLER_21_228 VGND VGND VPWR VPWR sky130_fd_sc_hd__decap_3
XFILLER_34_578 VGND VGND VPWR VPWR sky130_fd_sc_hd__decap_3
XFILLER_34_589 VGND VGND VPWR VPWR sky130_fd_sc_hd__decap_3
XFILLER_61_386 VGND VGND VPWR VPWR sky130_fd_sc_hd__decap_3
XFILLER_14_280 VGND VGND VPWR VPWR sky130_fd_sc_hd__decap_3
X_4731_ _4731_/A _4731_/B VGND VGND VPWR VPWR _7007_/D sky130_fd_sc_hd__and2_2
XFILLER_119_116 VGND VGND VPWR VPWR sky130_fd_sc_hd__fill_2
XFILLER_119_127 VGND VGND VPWR VPWR sky130_fd_sc_hd__decap_3
X_4662_ _4969_/B _4457_/X _4660_/X _4811_/C _4040_/Y VGND VGND VPWR VPWR _4662_/Y
+ sky130_fd_sc_hd__a221oi_2
XFILLER_119_138 VGND VGND VPWR VPWR sky130_fd_sc_hd__fill_2
X_6401_ _6626_/A VGND VGND VPWR VPWR _6401_/Y sky130_fd_sc_hd__inv_2
X_3613_ _3603_/Y _3606_/X _3612_/X VGND VGND VPWR VPWR _3614_/B sky130_fd_sc_hd__a21oi_2
X_7381_ _7388_/CLK _7381_/D _6661_/Y VGND VGND VPWR VPWR _7381_/Q sky130_fd_sc_hd__dfrtp_2
Xhold903 _6764_/Q VGND VGND VPWR VPWR _6764_/D sky130_fd_sc_hd__dlygate4sd3_1
X_4593_ _4593_/A _4593_/B VGND VGND VPWR VPWR _7284_/D sky130_fd_sc_hd__and2_2
XTAP_TAPCELL_ROW_116_1712 VGND VPWR sky130_fd_sc_hd__tapvpwrvgnd_1
XFILLER_115_333 VGND VGND VPWR VPWR sky130_fd_sc_hd__decap_3
Xhold914 _6743_/Q VGND VGND VPWR VPWR _6743_/D sky130_fd_sc_hd__dlygate4sd3_1
Xhold925 _6914_/Q VGND VGND VPWR VPWR _6914_/D sky130_fd_sc_hd__dlygate4sd3_1
Xhold936 _6892_/Q VGND VGND VPWR VPWR _6892_/D sky130_fd_sc_hd__dlygate4sd3_1
X_6332_ _6617_/A VGND VGND VPWR VPWR _6332_/Y sky130_fd_sc_hd__inv_2
X_3544_ _3544_/A _3544_/B VGND VGND VPWR VPWR _3635_/A sky130_fd_sc_hd__nor2_2
XFILLER_115_355 VGND VGND VPWR VPWR sky130_fd_sc_hd__fill_2
XFILLER_88_206 VGND VGND VPWR VPWR sky130_fd_sc_hd__decap_3
Xhold947 _7065_/Q VGND VGND VPWR VPWR _7065_/D sky130_fd_sc_hd__dlygate4sd3_1
Xhold958 _7068_/Q VGND VGND VPWR VPWR _7068_/D sky130_fd_sc_hd__dlygate4sd3_1
Xhold969 _7104_/Q VGND VGND VPWR VPWR _7104_/D sky130_fd_sc_hd__dlygate4sd3_1
Xmax_cap677 place571/A VGND VGND VPWR VPWR _6622_/A sky130_fd_sc_hd__buf_2
Xmax_cap666 _5047_/Y VGND VGND VPWR VPWR _5084_/B sky130_fd_sc_hd__clkbuf_2
X_6263_ _6463_/A VGND VGND VPWR VPWR _6263_/Y sky130_fd_sc_hd__inv_2
X_3475_ _7248_/Q _4599_/S _3472_/X _3474_/X VGND VGND VPWR VPWR _3502_/A sky130_fd_sc_hd__a211oi_2
XFILLER_115_388 VGND VGND VPWR VPWR sky130_fd_sc_hd__decap_3
XFILLER_115_399 VGND VGND VPWR VPWR sky130_fd_sc_hd__fill_1
XFILLER_88_239 VGND VGND VPWR VPWR sky130_fd_sc_hd__decap_3
XFILLER_69_431 VGND VGND VPWR VPWR sky130_fd_sc_hd__decap_3
XFILLER_69_453 VGND VGND VPWR VPWR sky130_fd_sc_hd__decap_3
XFILLER_111_561 VGND VGND VPWR VPWR sky130_fd_sc_hd__decap_3
XFILLER_29_328 VGND VGND VPWR VPWR sky130_fd_sc_hd__decap_3
XFILLER_57_626 VGND VGND VPWR VPWR sky130_fd_sc_hd__decap_3
XFILLER_69_475 VGND VGND VPWR VPWR sky130_fd_sc_hd__decap_3
XFILLER_96_272 VGND VGND VPWR VPWR sky130_fd_sc_hd__fill_2
X_5145_ _5145_/A _3500_/Y VGND VGND VPWR VPWR _5145_/X sky130_fd_sc_hd__or2b_2
XFILLER_111_594 VGND VGND VPWR VPWR sky130_fd_sc_hd__decap_3
XFILLER_56_136 VGND VGND VPWR VPWR sky130_fd_sc_hd__decap_3
XFILLER_56_147 VGND VGND VPWR VPWR sky130_fd_sc_hd__decap_3
XFILLER_57_659 VGND VGND VPWR VPWR sky130_fd_sc_hd__decap_3
XFILLER_84_456 VGND VGND VPWR VPWR sky130_fd_sc_hd__decap_3
XFILLER_71_139 VGND VGND VPWR VPWR sky130_fd_sc_hd__fill_1
XFILLER_52_342 VGND VGND VPWR VPWR sky130_fd_sc_hd__decap_3
XFILLER_64_180 VGND VGND VPWR VPWR sky130_fd_sc_hd__decap_3
XFILLER_80_651 VGND VGND VPWR VPWR sky130_fd_sc_hd__decap_3
XFILLER_25_589 VGND VGND VPWR VPWR sky130_fd_sc_hd__decap_3
XFILLER_40_504 VGND VGND VPWR VPWR sky130_fd_sc_hd__decap_3
XFILLER_52_386 VGND VGND VPWR VPWR sky130_fd_sc_hd__decap_3
XFILLER_80_684 VGND VGND VPWR VPWR sky130_fd_sc_hd__decap_3
XFILLER_100_44 VGND VGND VPWR VPWR sky130_fd_sc_hd__fill_1
XFILLER_12_228 VGND VGND VPWR VPWR sky130_fd_sc_hd__decap_3
XFILLER_40_548 VGND VGND VPWR VPWR sky130_fd_sc_hd__decap_3
XFILLER_52_397 VGND VGND VPWR VPWR sky130_fd_sc_hd__fill_1
X_4929_ _4908_/B _4928_/Y _4857_/A VGND VGND VPWR VPWR _4929_/Y sky130_fd_sc_hd__o21ai_2
XFILLER_100_88 VGND VGND VPWR VPWR sky130_fd_sc_hd__decap_3
XFILLER_20_250 VGND VGND VPWR VPWR sky130_fd_sc_hd__fill_2
XFILLER_60_26 VGND VGND VPWR VPWR sky130_fd_sc_hd__fill_2
XFILLER_60_59 VGND VGND VPWR VPWR sky130_fd_sc_hd__decap_3
XFILLER_20_294 VGND VGND VPWR VPWR sky130_fd_sc_hd__decap_3
XTAP_TAPCELL_ROW_78_1239 VGND VPWR sky130_fd_sc_hd__tapvpwrvgnd_1
XTAP_TAPCELL_ROW_78_1228 VGND VPWR sky130_fd_sc_hd__tapvpwrvgnd_1
XFILLER_109_42 VGND VGND VPWR VPWR sky130_fd_sc_hd__decap_3
XFILLER_106_344 VGND VGND VPWR VPWR sky130_fd_sc_hd__decap_3
XFILLER_106_355 VGND VGND VPWR VPWR sky130_fd_sc_hd__fill_2
XFILLER_109_75 VGND VGND VPWR VPWR sky130_fd_sc_hd__decap_3
XFILLER_109_97 VGND VGND VPWR VPWR sky130_fd_sc_hd__decap_3
XFILLER_69_57 VGND VGND VPWR VPWR sky130_fd_sc_hd__decap_3
XFILLER_0_600 VGND VGND VPWR VPWR sky130_fd_sc_hd__decap_3
XFILLER_106_377 VGND VGND VPWR VPWR sky130_fd_sc_hd__decap_3
XFILLER_79_228 VGND VGND VPWR VPWR sky130_fd_sc_hd__decap_3
XFILLER_0_666 VGND VGND VPWR VPWR sky130_fd_sc_hd__decap_3
XFILLER_0_688 VGND VGND VPWR VPWR sky130_fd_sc_hd__decap_3
XFILLER_48_626 VGND VGND VPWR VPWR sky130_fd_sc_hd__decap_3
XFILLER_87_261 VGND VGND VPWR VPWR sky130_fd_sc_hd__decap_3
XFILLER_47_125 VGND VGND VPWR VPWR sky130_fd_sc_hd__decap_3
XFILLER_48_648 VGND VGND VPWR VPWR sky130_fd_sc_hd__decap_3
XFILLER_75_445 VGND VGND VPWR VPWR sky130_fd_sc_hd__decap_3
XFILLER_28_350 VGND VGND VPWR VPWR sky130_fd_sc_hd__decap_3
XFILLER_35_309 VGND VGND VPWR VPWR sky130_fd_sc_hd__decap_3
XFILLER_47_169 VGND VGND VPWR VPWR sky130_fd_sc_hd__decap_3
XFILLER_63_629 VGND VGND VPWR VPWR sky130_fd_sc_hd__decap_3
XFILLER_85_78 VGND VGND VPWR VPWR sky130_fd_sc_hd__decap_3
XTAP_TAPCELL_ROW_89_1368 VGND VPWR sky130_fd_sc_hd__tapvpwrvgnd_1
XFILLER_16_501 VGND VGND VPWR VPWR sky130_fd_sc_hd__decap_3
XFILLER_18_94 VGND VGND VPWR VPWR sky130_fd_sc_hd__decap_3
XFILLER_28_383 VGND VGND VPWR VPWR sky130_fd_sc_hd__decap_3
XFILLER_56_681 VGND VGND VPWR VPWR sky130_fd_sc_hd__decap_3
XFILLER_62_117 VGND VGND VPWR VPWR sky130_fd_sc_hd__decap_3
XFILLER_62_139 VGND VGND VPWR VPWR sky130_fd_sc_hd__fill_1
XTAP_TAPCELL_ROW_46_838 VGND VPWR sky130_fd_sc_hd__tapvpwrvgnd_1
XTAP_TAPCELL_ROW_46_827 VGND VPWR sky130_fd_sc_hd__tapvpwrvgnd_1
XFILLER_43_353 VGND VGND VPWR VPWR sky130_fd_sc_hd__fill_2
XFILLER_71_662 VGND VGND VPWR VPWR sky130_fd_sc_hd__decap_3
XFILLER_16_578 VGND VGND VPWR VPWR sky130_fd_sc_hd__decap_3
XFILLER_16_589 VGND VGND VPWR VPWR sky130_fd_sc_hd__decap_3
XFILLER_70_150 VGND VGND VPWR VPWR sky130_fd_sc_hd__decap_3
XFILLER_71_673 VGND VGND VPWR VPWR sky130_fd_sc_hd__decap_3
XFILLER_70_194 VGND VGND VPWR VPWR sky130_fd_sc_hd__fill_2
XTAP_TAPCELL_ROW_26_584 VGND VPWR sky130_fd_sc_hd__tapvpwrvgnd_1
XTAP_TAPCELL_ROW_100_1513 VGND VPWR sky130_fd_sc_hd__tapvpwrvgnd_1
XTAP_TAPCELL_ROW_100_1502 VGND VPWR sky130_fd_sc_hd__tapvpwrvgnd_1
XFILLER_117_609 VGND VGND VPWR VPWR sky130_fd_sc_hd__decap_3
XFILLER_11_261 VGND VGND VPWR VPWR sky130_fd_sc_hd__decap_3
XFILLER_7_221 VGND VGND VPWR VPWR sky130_fd_sc_hd__decap_3
XFILLER_50_81 VGND VGND VPWR VPWR sky130_fd_sc_hd__decap_3
XFILLER_7_287 VGND VGND VPWR VPWR sky130_fd_sc_hd__decap_3
XFILLER_98_548 VGND VGND VPWR VPWR sky130_fd_sc_hd__decap_3
XFILLER_112_358 VGND VGND VPWR VPWR sky130_fd_sc_hd__decap_3
XFILLER_3_493 VGND VGND VPWR VPWR sky130_fd_sc_hd__decap_3
XTAP_TAPCELL_ROW_111_1642 VGND VPWR sky130_fd_sc_hd__tapvpwrvgnd_1
XFILLER_38_103 VGND VGND VPWR VPWR sky130_fd_sc_hd__fill_1
XFILLER_39_604 VGND VGND VPWR VPWR sky130_fd_sc_hd__decap_3
XFILLER_39_626 VGND VGND VPWR VPWR sky130_fd_sc_hd__decap_3
XFILLER_94_710 VGND VGND VPWR VPWR sky130_fd_sc_hd__decap_3
XFILLER_38_136 VGND VGND VPWR VPWR sky130_fd_sc_hd__decap_3
XFILLER_39_659 VGND VGND VPWR VPWR sky130_fd_sc_hd__decap_3
XFILLER_93_231 VGND VGND VPWR VPWR sky130_fd_sc_hd__decap_3
XFILLER_26_309 VGND VGND VPWR VPWR sky130_fd_sc_hd__decap_3
XFILLER_38_147 VGND VGND VPWR VPWR sky130_fd_sc_hd__decap_3
XFILLER_38_158 VGND VGND VPWR VPWR sky130_fd_sc_hd__decap_3
XFILLER_54_618 VGND VGND VPWR VPWR sky130_fd_sc_hd__decap_3
XFILLER_66_467 VGND VGND VPWR VPWR sky130_fd_sc_hd__fill_1
X_6950_ clkload8/A _6950_/D VGND VGND VPWR VPWR _6950_/Q sky130_fd_sc_hd__dfxtp_2
XFILLER_81_415 VGND VGND VPWR VPWR sky130_fd_sc_hd__decap_3
XFILLER_93_275 VGND VGND VPWR VPWR sky130_fd_sc_hd__decap_3
XFILLER_46_180 VGND VGND VPWR VPWR sky130_fd_sc_hd__decap_3
XFILLER_62_651 VGND VGND VPWR VPWR sky130_fd_sc_hd__decap_3
X_6881_ _7189_/CLK _6881_/D VGND VGND VPWR VPWR _6881_/Q sky130_fd_sc_hd__dfxtp_2
XFILLER_22_526 VGND VGND VPWR VPWR sky130_fd_sc_hd__decap_3
XFILLER_61_161 VGND VGND VPWR VPWR sky130_fd_sc_hd__decap_3
XFILLER_62_684 VGND VGND VPWR VPWR sky130_fd_sc_hd__decap_3
XFILLER_61_172 VGND VGND VPWR VPWR sky130_fd_sc_hd__decap_3
XFILLER_61_194 VGND VGND VPWR VPWR sky130_fd_sc_hd__decap_3
XTAP_TAPCELL_ROW_62_1029 VGND VPWR sky130_fd_sc_hd__tapvpwrvgnd_1
XFILLER_30_570 VGND VGND VPWR VPWR sky130_fd_sc_hd__decap_3
XFILLER_30_592 VGND VGND VPWR VPWR sky130_fd_sc_hd__decap_3
XFILLER_107_119 VGND VGND VPWR VPWR sky130_fd_sc_hd__decap_3
X_4645_ _4633_/X _4903_/B _4644_/X _4096_/A VGND VGND VPWR VPWR _4646_/B sky130_fd_sc_hd__o211a_2
XFILLER_116_631 VGND VGND VPWR VPWR sky130_fd_sc_hd__decap_3
X_7364_ _7370_/CLK _7364_/D _6644_/Y VGND VGND VPWR VPWR _7364_/Q sky130_fd_sc_hd__dfrtp_2
Xhold700 _6750_/Q VGND VGND VPWR VPWR _6750_/D sky130_fd_sc_hd__dlygate4sd3_1
Xhold711 _6943_/Q VGND VGND VPWR VPWR _6943_/D sky130_fd_sc_hd__dlygate4sd3_1
XFILLER_116_675 VGND VGND VPWR VPWR sky130_fd_sc_hd__decap_3
Xhold722 _6726_/Q VGND VGND VPWR VPWR _6726_/D sky130_fd_sc_hd__dlygate4sd3_1
Xhold733 _6759_/Q VGND VGND VPWR VPWR _6759_/D sky130_fd_sc_hd__dlygate4sd3_1
Xhold744 _6736_/Q VGND VGND VPWR VPWR _6736_/D sky130_fd_sc_hd__dlygate4sd3_1
Xhold755 _6729_/Q VGND VGND VPWR VPWR _6729_/D sky130_fd_sc_hd__dlygate4sd3_1
X_6315_ _6463_/A VGND VGND VPWR VPWR _6315_/Y sky130_fd_sc_hd__inv_2
X_3527_ _3527_/A _3427_/B VGND VGND VPWR VPWR _4614_/A sky130_fd_sc_hd__nor2b_2
X_7295_ _7333_/CLK _7295_/D _6575_/Y VGND VGND VPWR VPWR _7295_/Q sky130_fd_sc_hd__dfrtp_2
Xhold766 _6735_/Q VGND VGND VPWR VPWR _6735_/D sky130_fd_sc_hd__dlygate4sd3_1
Xhold777 _6966_/Q VGND VGND VPWR VPWR _6966_/D sky130_fd_sc_hd__dlygate4sd3_1
Xhold788 _6822_/Q VGND VGND VPWR VPWR _6822_/D sky130_fd_sc_hd__dlygate4sd3_1
Xhold799 _6831_/Q VGND VGND VPWR VPWR _6831_/D sky130_fd_sc_hd__dlygate4sd3_1
X_3458_ _3544_/A _3506_/B VGND VGND VPWR VPWR _3458_/Y sky130_fd_sc_hd__nor2_2
XTAP_TAPCELL_ROW_73_1169 VGND VPWR sky130_fd_sc_hd__tapvpwrvgnd_1
XFILLER_57_401 VGND VGND VPWR VPWR sky130_fd_sc_hd__decap_3
XFILLER_97_570 VGND VGND VPWR VPWR sky130_fd_sc_hd__decap_3
X_3389_ _7347_/Q _4285_/B1 _3384_/X _3556_/A VGND VGND VPWR VPWR _3389_/X sky130_fd_sc_hd__a211o_2
XFILLER_29_136 VGND VGND VPWR VPWR sky130_fd_sc_hd__decap_3
X_5128_ _3733_/C _3904_/Y _4677_/B VGND VGND VPWR VPWR _5128_/Y sky130_fd_sc_hd__a21oi_2
XFILLER_84_242 VGND VGND VPWR VPWR sky130_fd_sc_hd__decap_3
XFILLER_84_253 VGND VGND VPWR VPWR sky130_fd_sc_hd__decap_3
XFILLER_38_681 VGND VGND VPWR VPWR sky130_fd_sc_hd__decap_3
XFILLER_45_629 VGND VGND VPWR VPWR sky130_fd_sc_hd__decap_3
XFILLER_84_275 VGND VGND VPWR VPWR sky130_fd_sc_hd__decap_3
X_5059_ _4832_/A _3859_/X _5662_/B VGND VGND VPWR VPWR _5059_/X sky130_fd_sc_hd__a21o_2
XFILLER_111_21 VGND VGND VPWR VPWR sky130_fd_sc_hd__decap_3
XFILLER_25_320 VGND VGND VPWR VPWR sky130_fd_sc_hd__fill_2
XFILLER_37_191 VGND VGND VPWR VPWR sky130_fd_sc_hd__decap_3
XFILLER_111_54 VGND VGND VPWR VPWR sky130_fd_sc_hd__fill_2
XFILLER_52_150 VGND VGND VPWR VPWR sky130_fd_sc_hd__decap_3
XFILLER_53_662 VGND VGND VPWR VPWR sky130_fd_sc_hd__decap_3
XFILLER_53_673 VGND VGND VPWR VPWR sky130_fd_sc_hd__decap_3
XFILLER_111_87 VGND VGND VPWR VPWR sky130_fd_sc_hd__fill_1
XFILLER_25_386 VGND VGND VPWR VPWR sky130_fd_sc_hd__decap_3
XFILLER_40_312 VGND VGND VPWR VPWR sky130_fd_sc_hd__decap_3
XFILLER_71_36 VGND VGND VPWR VPWR sky130_fd_sc_hd__decap_3
XTAP_TAPCELL_ROW_23_543 VGND VPWR sky130_fd_sc_hd__tapvpwrvgnd_1
XTAP_TAPCELL_ROW_51_896 VGND VPWR sky130_fd_sc_hd__tapvpwrvgnd_1
XPHY_EDGE_ROW_109_Right_109 VGND VGND VPWR VPWR sky130_fd_sc_hd__decap_3
XFILLER_5_703 VGND VGND VPWR VPWR sky130_fd_sc_hd__decap_3
XFILLER_107_620 VGND VGND VPWR VPWR sky130_fd_sc_hd__decap_3
XFILLER_119_480 VGND VGND VPWR VPWR sky130_fd_sc_hd__decap_3
XFILLER_107_653 VGND VGND VPWR VPWR sky130_fd_sc_hd__decap_3
XFILLER_106_163 VGND VGND VPWR VPWR sky130_fd_sc_hd__decap_3
XFILLER_107_697 VGND VGND VPWR VPWR sky130_fd_sc_hd__decap_3
XFILLER_4_268 VGND VGND VPWR VPWR sky130_fd_sc_hd__decap_3
XFILLER_106_185 VGND VGND VPWR VPWR sky130_fd_sc_hd__decap_3
XFILLER_0_441 VGND VGND VPWR VPWR sky130_fd_sc_hd__fill_1
XFILLER_0_452 VGND VGND VPWR VPWR sky130_fd_sc_hd__decap_3
XFILLER_76_710 VGND VGND VPWR VPWR sky130_fd_sc_hd__decap_3
XFILLER_96_66 VGND VGND VPWR VPWR sky130_fd_sc_hd__fill_1
XFILLER_96_77 VGND VGND VPWR VPWR sky130_fd_sc_hd__decap_3
XFILLER_0_474 VGND VGND VPWR VPWR sky130_fd_sc_hd__fill_2
XFILLER_29_60 VGND VGND VPWR VPWR sky130_fd_sc_hd__decap_3
XFILLER_75_220 VGND VGND VPWR VPWR sky130_fd_sc_hd__decap_3
XFILLER_88_581 VGND VGND VPWR VPWR sky130_fd_sc_hd__decap_3
XFILLER_96_88 VGND VGND VPWR VPWR sky130_fd_sc_hd__fill_1
XFILLER_96_99 VGND VGND VPWR VPWR sky130_fd_sc_hd__decap_3
XFILLER_36_607 VGND VGND VPWR VPWR sky130_fd_sc_hd__decap_3
XFILLER_63_404 VGND VGND VPWR VPWR sky130_fd_sc_hd__decap_3
XFILLER_75_231 VGND VGND VPWR VPWR sky130_fd_sc_hd__decap_3
XFILLER_75_297 VGND VGND VPWR VPWR sky130_fd_sc_hd__fill_1
Xplace404 _3449_/X VGND VGND VPWR VPWR _4337_/B sky130_fd_sc_hd__buf_2
XTAP_TAPCELL_ROW_59_996 VGND VPWR sky130_fd_sc_hd__tapvpwrvgnd_1
XFILLER_28_180 VGND VGND VPWR VPWR sky130_fd_sc_hd__decap_3
XFILLER_35_139 VGND VGND VPWR VPWR sky130_fd_sc_hd__decap_3
XFILLER_44_640 VGND VGND VPWR VPWR sky130_fd_sc_hd__decap_3
XFILLER_44_651 VGND VGND VPWR VPWR sky130_fd_sc_hd__decap_3
Xplace437 _5229_/C VGND VGND VPWR VPWR _4348_/B1 sky130_fd_sc_hd__buf_2
Xplace426 _4832_/A VGND VGND VPWR VPWR _4799_/A sky130_fd_sc_hd__buf_2
Xplace415 _5136_/S VGND VGND VPWR VPWR _4335_/A2 sky130_fd_sc_hd__buf_2
XTAP_TAPCELL_ROW_3_290 VGND VPWR sky130_fd_sc_hd__tapvpwrvgnd_1
XFILLER_44_684 VGND VGND VPWR VPWR sky130_fd_sc_hd__decap_3
XFILLER_45_81 VGND VGND VPWR VPWR sky130_fd_sc_hd__fill_1
XFILLER_90_289 VGND VGND VPWR VPWR sky130_fd_sc_hd__decap_3
Xplace459 _4244_/B VGND VGND VPWR VPWR _4269_/B1 sky130_fd_sc_hd__buf_2
Xplace448 _5323_/S VGND VGND VPWR VPWR _5340_/S sky130_fd_sc_hd__buf_2
XFILLER_43_172 VGND VGND VPWR VPWR sky130_fd_sc_hd__decap_3
XFILLER_31_345 VGND VGND VPWR VPWR sky130_fd_sc_hd__decap_3
XFILLER_31_378 VGND VGND VPWR VPWR sky130_fd_sc_hd__decap_3
XFILLER_84_6 VGND VGND VPWR VPWR sky130_fd_sc_hd__decap_3
XFILLER_12_581 VGND VGND VPWR VPWR sky130_fd_sc_hd__decap_3
XFILLER_117_406 VGND VGND VPWR VPWR sky130_fd_sc_hd__decap_3
XFILLER_12_592 VGND VGND VPWR VPWR sky130_fd_sc_hd__decap_3
XFILLER_8_563 VGND VGND VPWR VPWR sky130_fd_sc_hd__decap_3
XANTENNA_2 _7293_/Q VGND VGND VPWR VPWR sky130_fd_sc_hd__diode_2
X_4430_ _7239_/Q _4430_/A2 _4459_/C1 _7175_/Q _4429_/X VGND VGND VPWR VPWR _4430_/X
+ sky130_fd_sc_hd__a221o_2
XFILLER_113_612 VGND VGND VPWR VPWR sky130_fd_sc_hd__decap_3
XFILLER_113_623 VGND VGND VPWR VPWR sky130_fd_sc_hd__decap_3
XFILLER_98_301 VGND VGND VPWR VPWR sky130_fd_sc_hd__decap_3
XFILLER_98_312 VGND VGND VPWR VPWR sky130_fd_sc_hd__decap_3
X_4361_ _4619_/A _4619_/B _5101_/B _5073_/A VGND VGND VPWR VPWR _4361_/X sky130_fd_sc_hd__and4_2
XFILLER_113_656 VGND VGND VPWR VPWR sky130_fd_sc_hd__decap_3
XFILLER_3_290 VGND VGND VPWR VPWR sky130_fd_sc_hd__fill_2
XFILLER_98_345 VGND VGND VPWR VPWR sky130_fd_sc_hd__decap_3
X_7080_ _7406_/CLK _7080_/D _6360_/Y VGND VGND VPWR VPWR _7080_/Q sky130_fd_sc_hd__dfrtp_2
X_4292_ _4292_/A _4292_/B _4292_/C VGND VGND VPWR VPWR _4292_/X sky130_fd_sc_hd__and3_2
X_3312_ _3340_/A _4467_/A _3519_/B _3310_/Y _5671_/A VGND VGND VPWR VPWR _5646_/A
+ sky130_fd_sc_hd__a311o_2
XFILLER_112_166 VGND VGND VPWR VPWR sky130_fd_sc_hd__decap_3
XFILLER_58_209 VGND VGND VPWR VPWR sky130_fd_sc_hd__decap_3
XFILLER_86_518 VGND VGND VPWR VPWR sky130_fd_sc_hd__decap_3
XFILLER_100_339 VGND VGND VPWR VPWR sky130_fd_sc_hd__fill_1
XFILLER_39_445 VGND VGND VPWR VPWR sky130_fd_sc_hd__decap_3
XFILLER_66_242 VGND VGND VPWR VPWR sky130_fd_sc_hd__decap_3
XFILLER_26_106 VGND VGND VPWR VPWR sky130_fd_sc_hd__decap_3
XFILLER_27_629 VGND VGND VPWR VPWR sky130_fd_sc_hd__decap_3
XFILLER_66_297 VGND VGND VPWR VPWR sky130_fd_sc_hd__decap_3
XFILLER_82_713 VGND VGND VPWR VPWR sky130_fd_sc_hd__fill_1
XFILLER_81_223 VGND VGND VPWR VPWR sky130_fd_sc_hd__fill_1
XFILLER_81_245 VGND VGND VPWR VPWR sky130_fd_sc_hd__decap_3
X_6933_ _6941_/CLK _6933_/D VGND VGND VPWR VPWR _6933_/Q sky130_fd_sc_hd__dfxtp_2
XFILLER_35_662 VGND VGND VPWR VPWR sky130_fd_sc_hd__decap_3
XFILLER_35_673 VGND VGND VPWR VPWR sky130_fd_sc_hd__decap_3
X_6864_ _6942_/CLK _6864_/D VGND VGND VPWR VPWR _6864_/Q sky130_fd_sc_hd__dfxtp_2
XFILLER_22_312 VGND VGND VPWR VPWR sky130_fd_sc_hd__decap_3
XFILLER_50_632 VGND VGND VPWR VPWR sky130_fd_sc_hd__decap_3
XFILLER_50_654 VGND VGND VPWR VPWR sky130_fd_sc_hd__decap_3
X_6795_ _6943_/CLK _6795_/D VGND VGND VPWR VPWR _6795_/Q sky130_fd_sc_hd__dfxtp_2
XFILLER_50_687 VGND VGND VPWR VPWR sky130_fd_sc_hd__decap_3
XTAP_TAPCELL_ROW_20_513 VGND VPWR sky130_fd_sc_hd__tapvpwrvgnd_1
XTAP_TAPCELL_ROW_20_502 VGND VPWR sky130_fd_sc_hd__tapvpwrvgnd_1
X_4628_ _4628_/A VGND VGND VPWR VPWR _4629_/A sky130_fd_sc_hd__inv_2
XFILLER_103_100 VGND VGND VPWR VPWR sky130_fd_sc_hd__decap_3
XFILLER_104_601 VGND VGND VPWR VPWR sky130_fd_sc_hd__decap_3
XFILLER_89_301 VGND VGND VPWR VPWR sky130_fd_sc_hd__decap_3
X_7347_ _7350_/CLK _7347_/D _6627_/Y VGND VGND VPWR VPWR _7347_/Q sky130_fd_sc_hd__dfrtp_2
X_4559_ _4559_/A _4577_/B VGND VGND VPWR VPWR _7301_/D sky130_fd_sc_hd__and2_2
XFILLER_103_122 VGND VGND VPWR VPWR sky130_fd_sc_hd__decap_3
XFILLER_104_634 VGND VGND VPWR VPWR sky130_fd_sc_hd__decap_3
XFILLER_104_645 VGND VGND VPWR VPWR sky130_fd_sc_hd__decap_3
X_7278_ _7374_/CLK _7278_/D _6558_/Y VGND VGND VPWR VPWR _7278_/Q sky130_fd_sc_hd__dfrtp_2
XFILLER_103_155 VGND VGND VPWR VPWR sky130_fd_sc_hd__decap_3
XFILLER_104_678 VGND VGND VPWR VPWR sky130_fd_sc_hd__decap_3
XFILLER_58_710 VGND VGND VPWR VPWR sky130_fd_sc_hd__decap_3
XFILLER_66_25 VGND VGND VPWR VPWR sky130_fd_sc_hd__decap_3
XFILLER_106_98 VGND VGND VPWR VPWR sky130_fd_sc_hd__decap_3
XFILLER_18_607 VGND VGND VPWR VPWR sky130_fd_sc_hd__decap_3
XFILLER_57_231 VGND VGND VPWR VPWR sky130_fd_sc_hd__decap_3
XFILLER_66_58 VGND VGND VPWR VPWR sky130_fd_sc_hd__decap_3
Xhold1230 _7166_/Q VGND VGND VPWR VPWR _5329_/A0 sky130_fd_sc_hd__dlygate4sd3_1
Xhold1241 _7202_/Q VGND VGND VPWR VPWR _5256_/A0 sky130_fd_sc_hd__dlygate4sd3_1
Xhold1252 _7304_/Q VGND VGND VPWR VPWR _4552_/A sky130_fd_sc_hd__dlygate4sd3_1
XFILLER_45_426 VGND VGND VPWR VPWR sky130_fd_sc_hd__decap_3
Xhold1263 _7128_/Q VGND VGND VPWR VPWR _5411_/A0 sky130_fd_sc_hd__dlygate4sd3_1
Xhold1274 _7133_/Q VGND VGND VPWR VPWR _5400_/A0 sky130_fd_sc_hd__dlygate4sd3_1
Xhold1285 _7238_/Q VGND VGND VPWR VPWR _5179_/A sky130_fd_sc_hd__dlygate4sd3_1
XTAP_TAPCELL_ROW_86_1327 VGND VPWR sky130_fd_sc_hd__tapvpwrvgnd_1
XTAP_TAPCELL_ROW_28_613 VGND VPWR sky130_fd_sc_hd__tapvpwrvgnd_1
XTAP_TAPCELL_ROW_28_602 VGND VPWR sky130_fd_sc_hd__tapvpwrvgnd_1
XFILLER_26_640 VGND VGND VPWR VPWR sky130_fd_sc_hd__decap_3
Xhold1296 _7221_/Q VGND VGND VPWR VPWR _5215_/A sky130_fd_sc_hd__dlygate4sd3_1
XTAP_TAPCELL_ROW_86_1338 VGND VPWR sky130_fd_sc_hd__tapvpwrvgnd_1
XTAP_TAPCELL_ROW_56_955 VGND VPWR sky130_fd_sc_hd__tapvpwrvgnd_1
XFILLER_26_651 VGND VGND VPWR VPWR sky130_fd_sc_hd__decap_3
XFILLER_26_684 VGND VGND VPWR VPWR sky130_fd_sc_hd__decap_3
XFILLER_60_429 VGND VGND VPWR VPWR sky130_fd_sc_hd__decap_3
XFILLER_72_267 VGND VGND VPWR VPWR sky130_fd_sc_hd__decap_3
XTAP_TAPCELL_ROW_0_260 VGND VPWR sky130_fd_sc_hd__tapvpwrvgnd_1
XFILLER_13_334 VGND VGND VPWR VPWR sky130_fd_sc_hd__fill_2
XFILLER_41_632 VGND VGND VPWR VPWR sky130_fd_sc_hd__decap_3
XFILLER_82_79 VGND VGND VPWR VPWR sky130_fd_sc_hd__decap_3
XFILLER_13_367 VGND VGND VPWR VPWR sky130_fd_sc_hd__decap_3
XFILLER_40_131 VGND VGND VPWR VPWR sky130_fd_sc_hd__decap_3
XFILLER_41_665 VGND VGND VPWR VPWR sky130_fd_sc_hd__decap_3
XFILLER_41_676 VGND VGND VPWR VPWR sky130_fd_sc_hd__decap_3
XFILLER_9_305 VGND VGND VPWR VPWR sky130_fd_sc_hd__decap_3
XFILLER_40_175 VGND VGND VPWR VPWR sky130_fd_sc_hd__decap_3
XFILLER_40_197 VGND VGND VPWR VPWR sky130_fd_sc_hd__decap_3
XFILLER_5_500 VGND VGND VPWR VPWR sky130_fd_sc_hd__decap_3
XFILLER_5_511 VGND VGND VPWR VPWR sky130_fd_sc_hd__decap_3
XFILLER_5_533 VGND VGND VPWR VPWR sky130_fd_sc_hd__decap_3
XTAP_TAPCELL_ROW_97_1467 VGND VPWR sky130_fd_sc_hd__tapvpwrvgnd_1
XFILLER_107_461 VGND VGND VPWR VPWR sky130_fd_sc_hd__decap_3
XFILLER_5_588 VGND VGND VPWR VPWR sky130_fd_sc_hd__decap_3
XFILLER_107_494 VGND VGND VPWR VPWR sky130_fd_sc_hd__decap_3
XFILLER_110_604 VGND VGND VPWR VPWR sky130_fd_sc_hd__decap_3
XFILLER_68_518 VGND VGND VPWR VPWR sky130_fd_sc_hd__decap_3
XTAP_TAPCELL_ROW_8_360 VGND VPWR sky130_fd_sc_hd__tapvpwrvgnd_1
XFILLER_110_637 VGND VGND VPWR VPWR sky130_fd_sc_hd__decap_3
XFILLER_110_648 VGND VGND VPWR VPWR sky130_fd_sc_hd__decap_3
XFILLER_95_326 VGND VGND VPWR VPWR sky130_fd_sc_hd__decap_3
XFILLER_95_337 VGND VGND VPWR VPWR sky130_fd_sc_hd__decap_3
XFILLER_48_253 VGND VGND VPWR VPWR sky130_fd_sc_hd__decap_3
XFILLER_95_359 VGND VGND VPWR VPWR sky130_fd_sc_hd__decap_3
XFILLER_64_713 VGND VGND VPWR VPWR sky130_fd_sc_hd__fill_1
XFILLER_36_448 VGND VGND VPWR VPWR sky130_fd_sc_hd__decap_3
XFILLER_48_297 VGND VGND VPWR VPWR sky130_fd_sc_hd__decap_3
XFILLER_56_80 VGND VGND VPWR VPWR sky130_fd_sc_hd__decap_3
XFILLER_63_234 VGND VGND VPWR VPWR sky130_fd_sc_hd__decap_3
XFILLER_91_532 VGND VGND VPWR VPWR sky130_fd_sc_hd__decap_3
XFILLER_17_662 VGND VGND VPWR VPWR sky130_fd_sc_hd__decap_3
XFILLER_17_673 VGND VGND VPWR VPWR sky130_fd_sc_hd__decap_3
XFILLER_51_407 VGND VGND VPWR VPWR sky130_fd_sc_hd__fill_1
XFILLER_32_610 VGND VGND VPWR VPWR sky130_fd_sc_hd__decap_3
XFILLER_44_492 VGND VGND VPWR VPWR sky130_fd_sc_hd__decap_3
XTAP_TAPCELL_ROW_106_1585 VGND VPWR sky130_fd_sc_hd__tapvpwrvgnd_1
XFILLER_32_643 VGND VGND VPWR VPWR sky130_fd_sc_hd__fill_1
XFILLER_32_654 VGND VGND VPWR VPWR sky130_fd_sc_hd__decap_3
XFILLER_31_175 VGND VGND VPWR VPWR sky130_fd_sc_hd__decap_3
XFILLER_32_687 VGND VGND VPWR VPWR sky130_fd_sc_hd__decap_3
XFILLER_82_3 VGND VGND VPWR VPWR sky130_fd_sc_hd__decap_3
X_6580_ _6612_/A VGND VGND VPWR VPWR _6580_/Y sky130_fd_sc_hd__inv_2
X_5600_ _5600_/A _5602_/B VGND VGND VPWR VPWR _7027_/D sky130_fd_sc_hd__and2_2
X_3792_ _3792_/A1 _3857_/A2 _4961_/A VGND VGND VPWR VPWR _7392_/D sky130_fd_sc_hd__a21o_2
XFILLER_118_704 VGND VGND VPWR VPWR sky130_fd_sc_hd__fill_2
XFILLER_117_225 VGND VGND VPWR VPWR sky130_fd_sc_hd__decap_3
XFILLER_105_409 VGND VGND VPWR VPWR sky130_fd_sc_hd__decap_3
X_7201_ _7400_/CLK _7201_/D _6481_/Y VGND VGND VPWR VPWR _7201_/Q sky130_fd_sc_hd__dfrtp_2
Xoutput602 _5651_/Y VGND VGND VPWR VPWR alu_result_out[8] sky130_fd_sc_hd__clkdlybuf4s25_1
Xoutput635 _6990_/Q VGND VGND VPWR VPWR pc_out[13] sky130_fd_sc_hd__clkdlybuf4s25_1
Xoutput624 _5642_/A VGND VGND VPWR VPWR instruction_out[3] sky130_fd_sc_hd__clkdlybuf4s25_1
Xoutput613 _3421_/B VGND VGND VPWR VPWR instruction_out[20] sky130_fd_sc_hd__clkdlybuf4s25_1
X_4413_ _4413_/A VGND VGND VPWR VPWR _4787_/A sky130_fd_sc_hd__inv_2
XFILLER_113_431 VGND VGND VPWR VPWR sky130_fd_sc_hd__decap_3
X_7132_ _7358_/CLK _7132_/D _6412_/Y VGND VGND VPWR VPWR _7132_/Q sky130_fd_sc_hd__dfrtp_2
Xoutput657 _3324_/A VGND VGND VPWR VPWR pc_out[4] sky130_fd_sc_hd__clkdlybuf4s25_1
Xoutput646 _7000_/Q VGND VGND VPWR VPWR pc_out[23] sky130_fd_sc_hd__clkdlybuf4s25_1
X_4344_ _4365_/A _4365_/B _4365_/C VGND VGND VPWR VPWR _4345_/B sky130_fd_sc_hd__a21bo_2
XFILLER_99_632 VGND VGND VPWR VPWR sky130_fd_sc_hd__decap_3
XFILLER_113_475 VGND VGND VPWR VPWR sky130_fd_sc_hd__decap_3
XFILLER_59_529 VGND VGND VPWR VPWR sky130_fd_sc_hd__decap_3
X_7063_ _7388_/CLK _7063_/D _6343_/Y VGND VGND VPWR VPWR _7063_/Q sky130_fd_sc_hd__dfrtp_2
XTAP_TAPCELL_ROW_70_1128 VGND VPWR sky130_fd_sc_hd__tapvpwrvgnd_1
XFILLER_99_676 VGND VGND VPWR VPWR sky130_fd_sc_hd__decap_3
XFILLER_99_665 VGND VGND VPWR VPWR sky130_fd_sc_hd__decap_3
XFILLER_100_125 VGND VGND VPWR VPWR sky130_fd_sc_hd__decap_3
XFILLER_101_626 VGND VGND VPWR VPWR sky130_fd_sc_hd__decap_3
XFILLER_86_326 VGND VGND VPWR VPWR sky130_fd_sc_hd__decap_3
XFILLER_98_197 VGND VGND VPWR VPWR sky130_fd_sc_hd__fill_2
X_4275_ _4275_/A _4274_/Y VGND VGND VPWR VPWR _4275_/Y sky130_fd_sc_hd__nor2b_2
XTAP_TAPCELL_ROW_70_1139 VGND VPWR sky130_fd_sc_hd__tapvpwrvgnd_1
XFILLER_100_147 VGND VGND VPWR VPWR sky130_fd_sc_hd__decap_3
XFILLER_101_659 VGND VGND VPWR VPWR sky130_fd_sc_hd__decap_3
XFILLER_39_220 VGND VGND VPWR VPWR sky130_fd_sc_hd__decap_3
XFILLER_39_231 VGND VGND VPWR VPWR sky130_fd_sc_hd__decap_3
XFILLER_39_264 VGND VGND VPWR VPWR sky130_fd_sc_hd__decap_3
XFILLER_39_275 VGND VGND VPWR VPWR sky130_fd_sc_hd__decap_3
XFILLER_54_212 VGND VGND VPWR VPWR sky130_fd_sc_hd__decap_3
XFILLER_82_510 VGND VGND VPWR VPWR sky130_fd_sc_hd__decap_3
XFILLER_82_543 VGND VGND VPWR VPWR sky130_fd_sc_hd__decap_3
XFILLER_94_381 VGND VGND VPWR VPWR sky130_fd_sc_hd__decap_3
XFILLER_14_109 VGND VGND VPWR VPWR sky130_fd_sc_hd__decap_3
XFILLER_54_256 VGND VGND VPWR VPWR sky130_fd_sc_hd__decap_3
XTAP_TAPCELL_ROW_53_925 VGND VPWR sky130_fd_sc_hd__tapvpwrvgnd_1
XFILLER_23_632 VGND VGND VPWR VPWR sky130_fd_sc_hd__decap_3
XFILLER_42_429 VGND VGND VPWR VPWR sky130_fd_sc_hd__decap_3
X_6916_ clkload8/A _6916_/D VGND VGND VPWR VPWR _6916_/Q sky130_fd_sc_hd__dfxtp_2
XFILLER_22_131 VGND VGND VPWR VPWR sky130_fd_sc_hd__decap_3
XFILLER_23_665 VGND VGND VPWR VPWR sky130_fd_sc_hd__decap_3
XFILLER_23_676 VGND VGND VPWR VPWR sky130_fd_sc_hd__decap_3
X_6847_ clkload5/A _6847_/D VGND VGND VPWR VPWR _6847_/Q sky130_fd_sc_hd__dfxtp_2
XFILLER_22_153 VGND VGND VPWR VPWR sky130_fd_sc_hd__decap_3
X_6778_ _6922_/CLK _6778_/D VGND VGND VPWR VPWR _6778_/Q sky130_fd_sc_hd__dfxtp_2
XTAP_TAPCELL_ROW_81_1268 VGND VPWR sky130_fd_sc_hd__tapvpwrvgnd_1
XTAP_TAPCELL_ROW_33_671 VGND VPWR sky130_fd_sc_hd__tapvpwrvgnd_1
XFILLER_10_337 VGND VGND VPWR VPWR sky130_fd_sc_hd__decap_3
XFILLER_22_197 VGND VGND VPWR VPWR sky130_fd_sc_hd__decap_3
X_5729_ _7370_/Q _5729_/A1 _5735_/S VGND VGND VPWR VPWR _6714_/D sky130_fd_sc_hd__mux2_2
XFILLER_108_203 VGND VGND VPWR VPWR sky130_fd_sc_hd__decap_3
XFILLER_117_20 VGND VGND VPWR VPWR sky130_fd_sc_hd__decap_3
XFILLER_117_53 VGND VGND VPWR VPWR sky130_fd_sc_hd__decap_3
XFILLER_2_525 VGND VGND VPWR VPWR sky130_fd_sc_hd__decap_3
XFILLER_2_536 VGND VGND VPWR VPWR sky130_fd_sc_hd__decap_3
XFILLER_89_131 VGND VGND VPWR VPWR sky130_fd_sc_hd__decap_3
XFILLER_104_453 VGND VGND VPWR VPWR sky130_fd_sc_hd__decap_3
XFILLER_117_75 VGND VGND VPWR VPWR sky130_fd_sc_hd__decap_3
XFILLER_2_569 VGND VGND VPWR VPWR sky130_fd_sc_hd__decap_3
XFILLER_104_486 VGND VGND VPWR VPWR sky130_fd_sc_hd__decap_3
XFILLER_77_337 VGND VGND VPWR VPWR sky130_fd_sc_hd__decap_3
XFILLER_77_57 VGND VGND VPWR VPWR sky130_fd_sc_hd__decap_3
XFILLER_77_79 VGND VGND VPWR VPWR sky130_fd_sc_hd__decap_3
XFILLER_58_551 VGND VGND VPWR VPWR sky130_fd_sc_hd__decap_3
XFILLER_100_681 VGND VGND VPWR VPWR sky130_fd_sc_hd__decap_3
XFILLER_18_404 VGND VGND VPWR VPWR sky130_fd_sc_hd__decap_3
XFILLER_46_713 VGND VGND VPWR VPWR sky130_fd_sc_hd__fill_1
XFILLER_85_370 VGND VGND VPWR VPWR sky130_fd_sc_hd__decap_3
XFILLER_92_318 VGND VGND VPWR VPWR sky130_fd_sc_hd__decap_3
XFILLER_92_329 VGND VGND VPWR VPWR sky130_fd_sc_hd__decap_3
Xhold1060 _7032_/Q VGND VGND VPWR VPWR _5591_/A sky130_fd_sc_hd__dlygate4sd3_1
XFILLER_18_459 VGND VGND VPWR VPWR sky130_fd_sc_hd__decap_3
XFILLER_45_212 VGND VGND VPWR VPWR sky130_fd_sc_hd__decap_3
XFILLER_73_543 VGND VGND VPWR VPWR sky130_fd_sc_hd__decap_3
Xhold1071 _7393_/Q VGND VGND VPWR VPWR _3770_/A1 sky130_fd_sc_hd__dlygate4sd3_1
Xhold1082 _6694_/Q VGND VGND VPWR VPWR _5688_/A1 sky130_fd_sc_hd__dlygate4sd3_1
Xhold1093 _7190_/Q VGND VGND VPWR VPWR _5280_/A0 sky130_fd_sc_hd__dlygate4sd3_1
XFILLER_93_78 VGND VGND VPWR VPWR sky130_fd_sc_hd__decap_3
XFILLER_14_610 VGND VGND VPWR VPWR sky130_fd_sc_hd__decap_3
XFILLER_26_492 VGND VGND VPWR VPWR sky130_fd_sc_hd__decap_3
XFILLER_14_643 VGND VGND VPWR VPWR sky130_fd_sc_hd__fill_1
XFILLER_14_654 VGND VGND VPWR VPWR sky130_fd_sc_hd__decap_3
XFILLER_26_94 VGND VGND VPWR VPWR sky130_fd_sc_hd__decap_3
XFILLER_13_175 VGND VGND VPWR VPWR sky130_fd_sc_hd__decap_3
XFILLER_14_687 VGND VGND VPWR VPWR sky130_fd_sc_hd__decap_3
XFILLER_9_113 VGND VGND VPWR VPWR sky130_fd_sc_hd__decap_3
XFILLER_42_71 VGND VGND VPWR VPWR sky130_fd_sc_hd__decap_3
XTAP_TAPCELL_ROW_11_398 VGND VPWR sky130_fd_sc_hd__tapvpwrvgnd_1
XFILLER_5_352 VGND VGND VPWR VPWR sky130_fd_sc_hd__decap_3
XFILLER_47_6 VGND VGND VPWR VPWR sky130_fd_sc_hd__decap_3
XFILLER_5_396 VGND VGND VPWR VPWR sky130_fd_sc_hd__decap_3
XFILLER_96_613 VGND VGND VPWR VPWR sky130_fd_sc_hd__decap_3
XFILLER_68_337 VGND VGND VPWR VPWR sky130_fd_sc_hd__fill_1
XFILLER_95_101 VGND VGND VPWR VPWR sky130_fd_sc_hd__decap_3
XFILLER_110_434 VGND VGND VPWR VPWR sky130_fd_sc_hd__decap_3
XFILLER_1_591 VGND VGND VPWR VPWR sky130_fd_sc_hd__decap_3
XFILLER_95_134 VGND VGND VPWR VPWR sky130_fd_sc_hd__decap_3
XFILLER_96_657 VGND VGND VPWR VPWR sky130_fd_sc_hd__decap_3
X_4060_ _7084_/Q _4102_/B _4432_/B1 _4059_/X VGND VGND VPWR VPWR _4068_/A sky130_fd_sc_hd__o211a_2
XFILLER_67_90 VGND VGND VPWR VPWR sky130_fd_sc_hd__fill_2
XFILLER_95_178 VGND VGND VPWR VPWR sky130_fd_sc_hd__decap_3
XTAP_TAPCELL_ROW_108_1614 VGND VPWR sky130_fd_sc_hd__tapvpwrvgnd_1
XTAP_TAPCELL_ROW_108_1603 VGND VPWR sky130_fd_sc_hd__tapvpwrvgnd_1
XFILLER_36_212 VGND VGND VPWR VPWR sky130_fd_sc_hd__decap_3
XFILLER_36_234 VGND VGND VPWR VPWR sky130_fd_sc_hd__decap_3
XFILLER_49_595 VGND VGND VPWR VPWR sky130_fd_sc_hd__fill_2
XFILLER_24_407 VGND VGND VPWR VPWR sky130_fd_sc_hd__fill_1
XFILLER_91_340 VGND VGND VPWR VPWR sky130_fd_sc_hd__decap_3
XFILLER_91_351 VGND VGND VPWR VPWR sky130_fd_sc_hd__decap_3
XFILLER_24_429 VGND VGND VPWR VPWR sky130_fd_sc_hd__decap_3
XFILLER_51_237 VGND VGND VPWR VPWR sky130_fd_sc_hd__decap_3
XFILLER_64_598 VGND VGND VPWR VPWR sky130_fd_sc_hd__decap_3
XFILLER_91_384 VGND VGND VPWR VPWR sky130_fd_sc_hd__decap_3
X_4962_ _6994_/Q _4977_/A VGND VGND VPWR VPWR _4963_/B sky130_fd_sc_hd__nor2_2
XTAP_TAPCELL_ROW_19_498 VGND VPWR sky130_fd_sc_hd__tapvpwrvgnd_1
XFILLER_32_440 VGND VGND VPWR VPWR sky130_fd_sc_hd__fill_1
XFILLER_32_451 VGND VGND VPWR VPWR sky130_fd_sc_hd__decap_3
X_6701_ _6944_/CLK _6701_/D VGND VGND VPWR VPWR _6701_/Q sky130_fd_sc_hd__dfxtp_2
X_4893_ _4928_/B _4943_/A _6996_/Q VGND VGND VPWR VPWR _4908_/B sky130_fd_sc_hd__o21a_2
X_3913_ _6857_/Q _3913_/A2 _3913_/B1 _6849_/Q _3912_/X VGND VGND VPWR VPWR _3913_/X
+ sky130_fd_sc_hd__a221o_2
XTAP_TAPCELL_ROW_67_1090 VGND VPWR sky130_fd_sc_hd__tapvpwrvgnd_1
XFILLER_20_613 VGND VGND VPWR VPWR sky130_fd_sc_hd__decap_3
X_6632_ _6632_/A VGND VGND VPWR VPWR _6632_/Y sky130_fd_sc_hd__inv_2
X_3844_ _3741_/X _3841_/X _3843_/X _3629_/A VGND VGND VPWR VPWR _3845_/B sky130_fd_sc_hd__a22o_2
XFILLER_20_657 VGND VGND VPWR VPWR sky130_fd_sc_hd__decap_3
XFILLER_32_495 VGND VGND VPWR VPWR sky130_fd_sc_hd__decap_3
XTAP_TAPCELL_ROW_30_630 VGND VPWR sky130_fd_sc_hd__tapvpwrvgnd_1
X_6563_ _6563_/A VGND VGND VPWR VPWR _6563_/Y sky130_fd_sc_hd__inv_2
X_3775_ _3714_/X _3772_/X _3774_/X _3733_/X VGND VGND VPWR VPWR _3775_/X sky130_fd_sc_hd__a22o_2
XTAP_TAPCELL_ROW_119_1743 VGND VPWR sky130_fd_sc_hd__tapvpwrvgnd_1
XFILLER_106_707 VGND VGND VPWR VPWR sky130_fd_sc_hd__decap_3
X_6494_ _6557_/A VGND VGND VPWR VPWR _6494_/Y sky130_fd_sc_hd__inv_2
XTAP_TAPCELL_ROW_119_1754 VGND VPWR sky130_fd_sc_hd__tapvpwrvgnd_1
XFILLER_9_691 VGND VGND VPWR VPWR sky130_fd_sc_hd__decap_3
XFILLER_118_578 VGND VGND VPWR VPWR sky130_fd_sc_hd__decap_3
XFILLER_118_589 VGND VGND VPWR VPWR sky130_fd_sc_hd__decap_3
XFILLER_105_228 VGND VGND VPWR VPWR sky130_fd_sc_hd__decap_3
XFILLER_59_304 VGND VGND VPWR VPWR sky130_fd_sc_hd__fill_2
X_7115_ _7372_/CLK _7115_/D _6395_/Y VGND VGND VPWR VPWR _7115_/Q sky130_fd_sc_hd__dfrtp_2
XFILLER_101_412 VGND VGND VPWR VPWR sky130_fd_sc_hd__decap_3
XFILLER_113_261 VGND VGND VPWR VPWR sky130_fd_sc_hd__fill_2
XFILLER_113_272 VGND VGND VPWR VPWR sky130_fd_sc_hd__decap_3
XFILLER_59_326 VGND VGND VPWR VPWR sky130_fd_sc_hd__decap_3
XFILLER_86_123 VGND VGND VPWR VPWR sky130_fd_sc_hd__decap_3
XFILLER_87_646 VGND VGND VPWR VPWR sky130_fd_sc_hd__decap_3
X_4327_ _4327_/A _4327_/B VGND VGND VPWR VPWR _4362_/C sky130_fd_sc_hd__nand2_2
XFILLER_99_495 VGND VGND VPWR VPWR sky130_fd_sc_hd__decap_3
XFILLER_101_445 VGND VGND VPWR VPWR sky130_fd_sc_hd__decap_3
XFILLER_86_156 VGND VGND VPWR VPWR sky130_fd_sc_hd__decap_3
XFILLER_87_679 VGND VGND VPWR VPWR sky130_fd_sc_hd__decap_3
X_7046_ _7403_/CLK _7046_/D _6326_/Y VGND VGND VPWR VPWR _7046_/Q sky130_fd_sc_hd__dfrtp_2
X_4258_ _4988_/A _4988_/B VGND VGND VPWR VPWR _5003_/A sky130_fd_sc_hd__or2_4
XFILLER_27_201 VGND VGND VPWR VPWR sky130_fd_sc_hd__decap_3
XFILLER_28_713 VGND VGND VPWR VPWR sky130_fd_sc_hd__fill_1
XFILLER_74_307 VGND VGND VPWR VPWR sky130_fd_sc_hd__fill_1
XFILLER_27_234 VGND VGND VPWR VPWR sky130_fd_sc_hd__decap_3
X_4189_ _7231_/Q _4421_/A2 _3366_/X _7167_/Q _4188_/X VGND VGND VPWR VPWR _4189_/X
+ sky130_fd_sc_hd__a221o_2
XTAP_TAPCELL_ROW_38_730 VGND VPWR sky130_fd_sc_hd__tapvpwrvgnd_1
XFILLER_103_66 VGND VGND VPWR VPWR sky130_fd_sc_hd__decap_3
XFILLER_27_267 VGND VGND VPWR VPWR sky130_fd_sc_hd__decap_3
XFILLER_55_554 VGND VGND VPWR VPWR sky130_fd_sc_hd__fill_1
XFILLER_103_88 VGND VGND VPWR VPWR sky130_fd_sc_hd__decap_3
XFILLER_42_215 VGND VGND VPWR VPWR sky130_fd_sc_hd__decap_3
XFILLER_70_546 VGND VGND VPWR VPWR sky130_fd_sc_hd__decap_3
XFILLER_42_259 VGND VGND VPWR VPWR sky130_fd_sc_hd__decap_3
XFILLER_23_484 VGND VGND VPWR VPWR sky130_fd_sc_hd__decap_3
XFILLER_11_635 VGND VGND VPWR VPWR sky130_fd_sc_hd__decap_3
XFILLER_23_495 VGND VGND VPWR VPWR sky130_fd_sc_hd__decap_3
XFILLER_7_606 VGND VGND VPWR VPWR sky130_fd_sc_hd__decap_3
XFILLER_109_512 VGND VGND VPWR VPWR sky130_fd_sc_hd__fill_2
XFILLER_109_523 VGND VGND VPWR VPWR sky130_fd_sc_hd__fill_1
XFILLER_11_668 VGND VGND VPWR VPWR sky130_fd_sc_hd__decap_3
XFILLER_11_679 VGND VGND VPWR VPWR sky130_fd_sc_hd__decap_3
XFILLER_7_617 VGND VGND VPWR VPWR sky130_fd_sc_hd__decap_3
XFILLER_6_138 VGND VGND VPWR VPWR sky130_fd_sc_hd__fill_2
XTAP_TAPCELL_ROW_94_1437 VGND VPWR sky130_fd_sc_hd__tapvpwrvgnd_1
XFILLER_88_23 VGND VGND VPWR VPWR sky130_fd_sc_hd__decap_3
XFILLER_2_344 VGND VGND VPWR VPWR sky130_fd_sc_hd__decap_3
XFILLER_88_67 VGND VGND VPWR VPWR sky130_fd_sc_hd__decap_3
XFILLER_104_283 VGND VGND VPWR VPWR sky130_fd_sc_hd__fill_1
XFILLER_78_635 VGND VGND VPWR VPWR sky130_fd_sc_hd__decap_3
XFILLER_78_657 VGND VGND VPWR VPWR sky130_fd_sc_hd__decap_3
XFILLER_92_115 VGND VGND VPWR VPWR sky130_fd_sc_hd__decap_3
XFILLER_93_638 VGND VGND VPWR VPWR sky130_fd_sc_hd__decap_3
XFILLER_46_521 VGND VGND VPWR VPWR sky130_fd_sc_hd__fill_1
XFILLER_86_690 VGND VGND VPWR VPWR sky130_fd_sc_hd__decap_3
XFILLER_18_267 VGND VGND VPWR VPWR sky130_fd_sc_hd__fill_2
XFILLER_37_82 VGND VGND VPWR VPWR sky130_fd_sc_hd__decap_3
XFILLER_37_93 VGND VGND VPWR VPWR sky130_fd_sc_hd__decap_3
XFILLER_61_502 VGND VGND VPWR VPWR sky130_fd_sc_hd__fill_2
XFILLER_92_159 VGND VGND VPWR VPWR sky130_fd_sc_hd__decap_3
XPHY_EDGE_ROW_16_Right_16 VGND VGND VPWR VPWR sky130_fd_sc_hd__decap_3
XFILLER_18_278 VGND VGND VPWR VPWR sky130_fd_sc_hd__decap_3
XFILLER_33_204 VGND VGND VPWR VPWR sky130_fd_sc_hd__decap_3
XFILLER_46_598 VGND VGND VPWR VPWR sky130_fd_sc_hd__decap_3
XFILLER_33_248 VGND VGND VPWR VPWR sky130_fd_sc_hd__decap_3
XFILLER_61_557 VGND VGND VPWR VPWR sky130_fd_sc_hd__decap_3
XTAP_TAPCELL_ROW_16_457 VGND VPWR sky130_fd_sc_hd__tapvpwrvgnd_1
XTAP_TAPCELL_ROW_103_1544 VGND VPWR sky130_fd_sc_hd__tapvpwrvgnd_1
XFILLER_14_451 VGND VGND VPWR VPWR sky130_fd_sc_hd__decap_3
XFILLER_119_309 VGND VGND VPWR VPWR sky130_fd_sc_hd__fill_1
XFILLER_41_270 VGND VGND VPWR VPWR sky130_fd_sc_hd__decap_3
XFILLER_41_281 VGND VGND VPWR VPWR sky130_fd_sc_hd__decap_3
XFILLER_10_690 VGND VGND VPWR VPWR sky130_fd_sc_hd__decap_3
X_3560_ _5118_/D _3560_/B VGND VGND VPWR VPWR _3562_/B sky130_fd_sc_hd__nor2_2
XPHY_EDGE_ROW_25_Right_25 VGND VGND VPWR VPWR sky130_fd_sc_hd__decap_3
XFILLER_6_672 VGND VGND VPWR VPWR sky130_fd_sc_hd__decap_3
XFILLER_115_548 VGND VGND VPWR VPWR sky130_fd_sc_hd__decap_3
X_3491_ _7215_/Q _3377_/X _3366_/X _7151_/Q _3490_/X VGND VGND VPWR VPWR _3491_/X
+ sky130_fd_sc_hd__a221o_2
XFILLER_69_613 VGND VGND VPWR VPWR sky130_fd_sc_hd__decap_3
XFILLER_69_635 VGND VGND VPWR VPWR sky130_fd_sc_hd__decap_3
XFILLER_96_410 VGND VGND VPWR VPWR sky130_fd_sc_hd__decap_3
X_5161_ _5161_/A _5641_/A VGND VGND VPWR VPWR _5211_/B sky130_fd_sc_hd__or2_2
XTAP_TAPCELL_ROW_114_1684 VGND VPWR sky130_fd_sc_hd__tapvpwrvgnd_1
XFILLER_69_668 VGND VGND VPWR VPWR sky130_fd_sc_hd__decap_3
XFILLER_69_679 VGND VGND VPWR VPWR sky130_fd_sc_hd__decap_3
XFILLER_96_454 VGND VGND VPWR VPWR sky130_fd_sc_hd__decap_3
X_5092_ _5069_/B _5092_/B _5092_/C VGND VGND VPWR VPWR _5092_/X sky130_fd_sc_hd__and3b_2
X_4112_ _7332_/Q _3952_/S _4233_/B1 _7300_/Q VGND VGND VPWR VPWR _4112_/X sky130_fd_sc_hd__a22o_2
XFILLER_110_253 VGND VGND VPWR VPWR sky130_fd_sc_hd__decap_3
XFILLER_56_318 VGND VGND VPWR VPWR sky130_fd_sc_hd__fill_1
XFILLER_68_156 VGND VGND VPWR VPWR sky130_fd_sc_hd__decap_3
XFILLER_96_487 VGND VGND VPWR VPWR sky130_fd_sc_hd__decap_3
X_4043_ _7309_/Q _4419_/A2 _4421_/B1 _7181_/Q _4042_/X VGND VGND VPWR VPWR _4043_/X
+ sky130_fd_sc_hd__a221o_2
XFILLER_49_370 VGND VGND VPWR VPWR sky130_fd_sc_hd__decap_3
XPHY_EDGE_ROW_34_Right_34 VGND VGND VPWR VPWR sky130_fd_sc_hd__decap_3
XFILLER_64_362 VGND VGND VPWR VPWR sky130_fd_sc_hd__fill_2
XFILLER_92_660 VGND VGND VPWR VPWR sky130_fd_sc_hd__decap_3
XFILLER_24_215 VGND VGND VPWR VPWR sky130_fd_sc_hd__decap_3
XFILLER_52_524 VGND VGND VPWR VPWR sky130_fd_sc_hd__decap_3
XFILLER_64_384 VGND VGND VPWR VPWR sky130_fd_sc_hd__decap_3
XFILLER_91_181 VGND VGND VPWR VPWR sky130_fd_sc_hd__decap_3
XFILLER_92_693 VGND VGND VPWR VPWR sky130_fd_sc_hd__decap_3
XTAP_TAPCELL_ROW_35_700 VGND VPWR sky130_fd_sc_hd__tapvpwrvgnd_1
XFILLER_24_248 VGND VGND VPWR VPWR sky130_fd_sc_hd__decap_3
XFILLER_24_259 VGND VGND VPWR VPWR sky130_fd_sc_hd__decap_3
X_4945_ _4836_/S _6995_/D _5657_/C _4944_/X VGND VGND VPWR VPWR _4945_/X sky130_fd_sc_hd__o22a_2
XFILLER_52_579 VGND VGND VPWR VPWR sky130_fd_sc_hd__fill_1
XFILLER_20_421 VGND VGND VPWR VPWR sky130_fd_sc_hd__fill_1
X_6615_ _6651_/A VGND VGND VPWR VPWR _6615_/Y sky130_fd_sc_hd__inv_2
X_3827_ _6700_/Q _3913_/B1 _3912_/B1 _6878_/Q VGND VGND VPWR VPWR _3827_/X sky130_fd_sc_hd__a22o_2
XPHY_EDGE_ROW_43_Right_43 VGND VGND VPWR VPWR sky130_fd_sc_hd__decap_3
X_6546_ _6642_/A VGND VGND VPWR VPWR _6546_/Y sky130_fd_sc_hd__inv_2
XFILLER_106_515 VGND VGND VPWR VPWR sky130_fd_sc_hd__decap_3
XFILLER_116_9 VGND VGND VPWR VPWR sky130_fd_sc_hd__decap_3
XFILLER_118_386 VGND VGND VPWR VPWR sky130_fd_sc_hd__fill_2
X_6477_ _6667_/A VGND VGND VPWR VPWR _6477_/Y sky130_fd_sc_hd__inv_2
XPHY_EDGE_ROW_18_Left_138 VGND VGND VPWR VPWR sky130_fd_sc_hd__decap_3
XFILLER_102_710 VGND VGND VPWR VPWR sky130_fd_sc_hd__decap_3
XFILLER_99_281 VGND VGND VPWR VPWR sky130_fd_sc_hd__decap_3
XFILLER_114_592 VGND VGND VPWR VPWR sky130_fd_sc_hd__decap_3
XFILLER_58_59 VGND VGND VPWR VPWR sky130_fd_sc_hd__decap_3
XFILLER_59_134 VGND VGND VPWR VPWR sky130_fd_sc_hd__decap_3
XFILLER_114_32 VGND VGND VPWR VPWR sky130_fd_sc_hd__decap_3
XFILLER_47_307 VGND VGND VPWR VPWR sky130_fd_sc_hd__decap_3
XFILLER_59_167 VGND VGND VPWR VPWR sky130_fd_sc_hd__fill_1
XFILLER_75_638 VGND VGND VPWR VPWR sky130_fd_sc_hd__decap_3
XFILLER_87_476 VGND VGND VPWR VPWR sky130_fd_sc_hd__decap_3
X_7029_ _7344_/CLK _7029_/D _6309_/Y VGND VGND VPWR VPWR _7029_/Q sky130_fd_sc_hd__dfrtp_2
XPHY_EDGE_ROW_52_Right_52 VGND VGND VPWR VPWR sky130_fd_sc_hd__decap_3
XFILLER_114_65 VGND VGND VPWR VPWR sky130_fd_sc_hd__decap_3
XFILLER_68_690 VGND VGND VPWR VPWR sky130_fd_sc_hd__decap_3
XFILLER_74_115 VGND VGND VPWR VPWR sky130_fd_sc_hd__decap_3
XFILLER_55_340 VGND VGND VPWR VPWR sky130_fd_sc_hd__decap_3
XFILLER_74_159 VGND VGND VPWR VPWR sky130_fd_sc_hd__decap_3
XFILLER_90_619 VGND VGND VPWR VPWR sky130_fd_sc_hd__decap_3
XPHY_EDGE_ROW_27_Left_147 VGND VGND VPWR VPWR sky130_fd_sc_hd__decap_3
XFILLER_28_598 VGND VGND VPWR VPWR sky130_fd_sc_hd__decap_3
XFILLER_55_384 VGND VGND VPWR VPWR sky130_fd_sc_hd__decap_3
XFILLER_83_671 VGND VGND VPWR VPWR sky130_fd_sc_hd__fill_1
XFILLER_83_682 VGND VGND VPWR VPWR sky130_fd_sc_hd__decap_3
XFILLER_15_237 VGND VGND VPWR VPWR sky130_fd_sc_hd__decap_3
XFILLER_15_259 VGND VGND VPWR VPWR sky130_fd_sc_hd__decap_3
XFILLER_43_557 VGND VGND VPWR VPWR sky130_fd_sc_hd__decap_3
XFILLER_70_354 VGND VGND VPWR VPWR sky130_fd_sc_hd__fill_1
XFILLER_70_365 VGND VGND VPWR VPWR sky130_fd_sc_hd__fill_2
XFILLER_11_432 VGND VGND VPWR VPWR sky130_fd_sc_hd__fill_1
XFILLER_23_281 VGND VGND VPWR VPWR sky130_fd_sc_hd__fill_1
XFILLER_30_229 VGND VGND VPWR VPWR sky130_fd_sc_hd__decap_3
XTAP_TAPCELL_ROW_13_416 VGND VPWR sky130_fd_sc_hd__tapvpwrvgnd_1
XPHY_EDGE_ROW_61_Right_61 VGND VGND VPWR VPWR sky130_fd_sc_hd__decap_3
XFILLER_11_454 VGND VGND VPWR VPWR sky130_fd_sc_hd__decap_3
XTAP_TAPCELL_ROW_41_769 VGND VPWR sky130_fd_sc_hd__tapvpwrvgnd_1
XFILLER_109_331 VGND VGND VPWR VPWR sky130_fd_sc_hd__decap_3
XFILLER_11_476 VGND VGND VPWR VPWR sky130_fd_sc_hd__decap_3
XFILLER_11_498 VGND VGND VPWR VPWR sky130_fd_sc_hd__decap_3
XFILLER_23_84 VGND VGND VPWR VPWR sky130_fd_sc_hd__fill_2
XFILLER_23_95 VGND VGND VPWR VPWR sky130_fd_sc_hd__decap_3
XFILLER_7_469 VGND VGND VPWR VPWR sky130_fd_sc_hd__decap_3
XPHY_EDGE_ROW_36_Left_156 VGND VGND VPWR VPWR sky130_fd_sc_hd__decap_3
XFILLER_99_33 VGND VGND VPWR VPWR sky130_fd_sc_hd__decap_3
XFILLER_109_386 VGND VGND VPWR VPWR sky130_fd_sc_hd__decap_3
XFILLER_3_620 VGND VGND VPWR VPWR sky130_fd_sc_hd__decap_3
XFILLER_99_77 VGND VGND VPWR VPWR sky130_fd_sc_hd__decap_3
XFILLER_3_653 VGND VGND VPWR VPWR sky130_fd_sc_hd__decap_3
XFILLER_97_207 VGND VGND VPWR VPWR sky130_fd_sc_hd__decap_3
XFILLER_105_570 VGND VGND VPWR VPWR sky130_fd_sc_hd__decap_3
XFILLER_2_141 VGND VGND VPWR VPWR sky130_fd_sc_hd__fill_1
XFILLER_3_697 VGND VGND VPWR VPWR sky130_fd_sc_hd__decap_3
XFILLER_78_421 VGND VGND VPWR VPWR sky130_fd_sc_hd__decap_3
XPHY_EDGE_ROW_70_Right_70 VGND VGND VPWR VPWR sky130_fd_sc_hd__decap_3
XFILLER_38_307 VGND VGND VPWR VPWR sky130_fd_sc_hd__fill_1
XFILLER_48_70 VGND VGND VPWR VPWR sky130_fd_sc_hd__decap_3
XFILLER_66_638 VGND VGND VPWR VPWR sky130_fd_sc_hd__decap_3
XFILLER_93_446 VGND VGND VPWR VPWR sky130_fd_sc_hd__fill_2
XPHY_EDGE_ROW_45_Left_165 VGND VGND VPWR VPWR sky130_fd_sc_hd__decap_3
XFILLER_74_660 VGND VGND VPWR VPWR sky130_fd_sc_hd__decap_3
XFILLER_81_608 VGND VGND VPWR VPWR sky130_fd_sc_hd__decap_3
XTAP_TAPCELL_ROW_49_869 VGND VPWR sky130_fd_sc_hd__tapvpwrvgnd_1
XFILLER_19_598 VGND VGND VPWR VPWR sky130_fd_sc_hd__decap_3
XFILLER_34_502 VGND VGND VPWR VPWR sky130_fd_sc_hd__decap_3
XFILLER_46_373 VGND VGND VPWR VPWR sky130_fd_sc_hd__decap_3
XFILLER_74_693 VGND VGND VPWR VPWR sky130_fd_sc_hd__decap_3
XFILLER_80_118 VGND VGND VPWR VPWR sky130_fd_sc_hd__decap_3
XFILLER_46_395 VGND VGND VPWR VPWR sky130_fd_sc_hd__decap_3
XTAP_TAPCELL_ROW_64_1060 VGND VPWR sky130_fd_sc_hd__tapvpwrvgnd_1
XFILLER_14_292 VGND VGND VPWR VPWR sky130_fd_sc_hd__decap_3
X_4730_ _7007_/Q _4738_/A VGND VGND VPWR VPWR _4731_/A sky130_fd_sc_hd__or2_2
X_7380_ _7388_/CLK _7380_/D _6660_/Y VGND VGND VPWR VPWR _7380_/Q sky130_fd_sc_hd__dfrtp_2
X_6400_ _6624_/A VGND VGND VPWR VPWR _6400_/Y sky130_fd_sc_hd__inv_2
X_3612_ _3536_/B _4614_/B _3610_/Y _3611_/Y VGND VGND VPWR VPWR _3612_/X sky130_fd_sc_hd__a211o_2
XPHY_EDGE_ROW_54_Left_174 VGND VGND VPWR VPWR sky130_fd_sc_hd__decap_3
Xhold904 _6903_/Q VGND VGND VPWR VPWR _6903_/D sky130_fd_sc_hd__dlygate4sd3_1
X_6331_ _6550_/A VGND VGND VPWR VPWR _6331_/Y sky130_fd_sc_hd__inv_2
XTAP_TAPCELL_ROW_116_1713 VGND VPWR sky130_fd_sc_hd__tapvpwrvgnd_1
XTAP_TAPCELL_ROW_116_1702 VGND VPWR sky130_fd_sc_hd__tapvpwrvgnd_1
Xhold915 _6746_/Q VGND VGND VPWR VPWR _6746_/D sky130_fd_sc_hd__dlygate4sd3_1
Xhold926 _6727_/Q VGND VGND VPWR VPWR _6727_/D sky130_fd_sc_hd__dlygate4sd3_1
Xhold937 _6875_/Q VGND VGND VPWR VPWR _6875_/D sky130_fd_sc_hd__dlygate4sd3_1
X_3543_ _3540_/X _3541_/X _5144_/A VGND VGND VPWR VPWR _3630_/B sky130_fd_sc_hd__o21ai_2
Xhold948 _7071_/Q VGND VGND VPWR VPWR _7071_/D sky130_fd_sc_hd__dlygate4sd3_1
Xhold959 _7063_/Q VGND VGND VPWR VPWR _7063_/D sky130_fd_sc_hd__dlygate4sd3_1
X_6262_ _6463_/A VGND VGND VPWR VPWR _6262_/Y sky130_fd_sc_hd__inv_2
X_3474_ _7280_/Q _4534_/S _3366_/X _7152_/Q _3473_/X VGND VGND VPWR VPWR _3474_/X
+ sky130_fd_sc_hd__a221o_2
XFILLER_115_378 VGND VGND VPWR VPWR sky130_fd_sc_hd__fill_1
XFILLER_88_218 VGND VGND VPWR VPWR sky130_fd_sc_hd__decap_3
X_5213_ _5213_/A _5225_/B VGND VGND VPWR VPWR _7222_/D sky130_fd_sc_hd__and2_2
XFILLER_69_443 VGND VGND VPWR VPWR sky130_fd_sc_hd__decap_3
X_5144_ _5144_/A _5144_/B VGND VGND VPWR VPWR _5145_/A sky130_fd_sc_hd__nand2_2
XFILLER_111_551 VGND VGND VPWR VPWR sky130_fd_sc_hd__fill_1
XFILLER_111_573 VGND VGND VPWR VPWR sky130_fd_sc_hd__decap_3
XFILLER_28_29 VGND VGND VPWR VPWR sky130_fd_sc_hd__decap_3
XFILLER_29_307 VGND VGND VPWR VPWR sky130_fd_sc_hd__decap_3
XFILLER_69_487 VGND VGND VPWR VPWR sky130_fd_sc_hd__decap_3
XFILLER_84_402 VGND VGND VPWR VPWR sky130_fd_sc_hd__decap_3
XFILLER_96_251 VGND VGND VPWR VPWR sky130_fd_sc_hd__fill_1
XPHY_EDGE_ROW_63_Left_183 VGND VGND VPWR VPWR sky130_fd_sc_hd__decap_3
XFILLER_56_115 VGND VGND VPWR VPWR sky130_fd_sc_hd__decap_3
XFILLER_57_638 VGND VGND VPWR VPWR sky130_fd_sc_hd__decap_3
XFILLER_84_424 VGND VGND VPWR VPWR sky130_fd_sc_hd__decap_3
X_5075_ _5075_/A _5075_/B _5075_/C VGND VGND VPWR VPWR _5658_/A sky130_fd_sc_hd__or3_2
XFILLER_37_340 VGND VGND VPWR VPWR sky130_fd_sc_hd__decap_3
XFILLER_72_619 VGND VGND VPWR VPWR sky130_fd_sc_hd__decap_3
XFILLER_84_468 VGND VGND VPWR VPWR sky130_fd_sc_hd__decap_3
XFILLER_65_671 VGND VGND VPWR VPWR sky130_fd_sc_hd__fill_1
XFILLER_65_682 VGND VGND VPWR VPWR sky130_fd_sc_hd__decap_3
XFILLER_52_321 VGND VGND VPWR VPWR sky130_fd_sc_hd__fill_1
XFILLER_64_192 VGND VGND VPWR VPWR sky130_fd_sc_hd__decap_3
XFILLER_80_630 VGND VGND VPWR VPWR sky130_fd_sc_hd__decap_3
XFILLER_52_365 VGND VGND VPWR VPWR sky130_fd_sc_hd__decap_3
XFILLER_80_663 VGND VGND VPWR VPWR sky130_fd_sc_hd__decap_3
XFILLER_80_696 VGND VGND VPWR VPWR sky130_fd_sc_hd__decap_3
X_4928_ _6996_/Q _4928_/B _4943_/A VGND VGND VPWR VPWR _4928_/Y sky130_fd_sc_hd__nor3_2
XFILLER_100_56 VGND VGND VPWR VPWR sky130_fd_sc_hd__decap_3
XPHY_EDGE_ROW_72_Left_192 VGND VGND VPWR VPWR sky130_fd_sc_hd__decap_3
XFILLER_20_262 VGND VGND VPWR VPWR sky130_fd_sc_hd__fill_1
X_4859_ _7000_/Q _4870_/A VGND VGND VPWR VPWR _4859_/Y sky130_fd_sc_hd__nor2_2
XFILLER_109_21 VGND VGND VPWR VPWR sky130_fd_sc_hd__decap_3
XFILLER_118_150 VGND VGND VPWR VPWR sky130_fd_sc_hd__decap_3
XFILLER_119_651 VGND VGND VPWR VPWR sky130_fd_sc_hd__decap_3
XFILLER_119_673 VGND VGND VPWR VPWR sky130_fd_sc_hd__decap_3
XFILLER_4_406 VGND VGND VPWR VPWR sky130_fd_sc_hd__decap_3
Xclkbuf_3_0__f_clk clkbuf_0_clk/X VGND VGND VPWR VPWR clkbuf_leaf_1_clk/A sky130_fd_sc_hd__clkbuf_16
XTAP_TAPCELL_ROW_78_1229 VGND VPWR sky130_fd_sc_hd__tapvpwrvgnd_1
XFILLER_106_301 VGND VGND VPWR VPWR sky130_fd_sc_hd__decap_3
XFILLER_106_312 VGND VGND VPWR VPWR sky130_fd_sc_hd__decap_3
XFILLER_109_54 VGND VGND VPWR VPWR sky130_fd_sc_hd__fill_2
XFILLER_118_183 VGND VGND VPWR VPWR sky130_fd_sc_hd__decap_3
XFILLER_4_428 VGND VGND VPWR VPWR sky130_fd_sc_hd__decap_3
X_6529_ _6626_/A VGND VGND VPWR VPWR _6529_/Y sky130_fd_sc_hd__inv_2
XFILLER_106_389 VGND VGND VPWR VPWR sky130_fd_sc_hd__decap_3
XFILLER_0_623 VGND VGND VPWR VPWR sky130_fd_sc_hd__decap_3
XFILLER_0_645 VGND VGND VPWR VPWR sky130_fd_sc_hd__decap_3
XFILLER_102_573 VGND VGND VPWR VPWR sky130_fd_sc_hd__decap_3
XFILLER_48_605 VGND VGND VPWR VPWR sky130_fd_sc_hd__decap_3
XFILLER_75_402 VGND VGND VPWR VPWR sky130_fd_sc_hd__fill_2
XFILLER_87_240 VGND VGND VPWR VPWR sky130_fd_sc_hd__decap_3
XFILLER_48_638 VGND VGND VPWR VPWR sky130_fd_sc_hd__decap_3
XFILLER_85_57 VGND VGND VPWR VPWR sky130_fd_sc_hd__decap_3
XFILLER_87_284 VGND VGND VPWR VPWR sky130_fd_sc_hd__decap_3
XFILLER_47_159 VGND VGND VPWR VPWR sky130_fd_sc_hd__decap_3
XFILLER_56_660 VGND VGND VPWR VPWR sky130_fd_sc_hd__decap_3
XTAP_TAPCELL_ROW_89_1369 VGND VPWR sky130_fd_sc_hd__tapvpwrvgnd_1
XFILLER_16_524 VGND VGND VPWR VPWR sky130_fd_sc_hd__decap_3
XFILLER_28_362 VGND VGND VPWR VPWR sky130_fd_sc_hd__fill_2
XFILLER_56_693 VGND VGND VPWR VPWR sky130_fd_sc_hd__decap_3
XFILLER_62_129 VGND VGND VPWR VPWR sky130_fd_sc_hd__fill_1
XFILLER_90_427 VGND VGND VPWR VPWR sky130_fd_sc_hd__decap_3
XTAP_TAPCELL_ROW_46_839 VGND VPWR sky130_fd_sc_hd__tapvpwrvgnd_1
XTAP_TAPCELL_ROW_46_828 VGND VPWR sky130_fd_sc_hd__tapvpwrvgnd_1
XFILLER_28_395 VGND VGND VPWR VPWR sky130_fd_sc_hd__decap_3
XFILLER_55_181 VGND VGND VPWR VPWR sky130_fd_sc_hd__fill_2
XFILLER_71_641 VGND VGND VPWR VPWR sky130_fd_sc_hd__decap_3
XFILLER_43_376 VGND VGND VPWR VPWR sky130_fd_sc_hd__decap_3
XFILLER_71_685 VGND VGND VPWR VPWR sky130_fd_sc_hd__decap_3
XFILLER_34_61 VGND VGND VPWR VPWR sky130_fd_sc_hd__decap_3
XTAP_TAPCELL_ROW_26_585 VGND VPWR sky130_fd_sc_hd__tapvpwrvgnd_1
XTAP_TAPCELL_ROW_100_1514 VGND VPWR sky130_fd_sc_hd__tapvpwrvgnd_1
XTAP_TAPCELL_ROW_100_1503 VGND VPWR sky130_fd_sc_hd__tapvpwrvgnd_1
XFILLER_8_701 VGND VGND VPWR VPWR sky130_fd_sc_hd__decap_3
XFILLER_11_251 VGND VGND VPWR VPWR sky130_fd_sc_hd__decap_3
XFILLER_11_273 VGND VGND VPWR VPWR sky130_fd_sc_hd__decap_3
XFILLER_79_9 VGND VGND VPWR VPWR sky130_fd_sc_hd__decap_3
XFILLER_7_200 VGND VGND VPWR VPWR sky130_fd_sc_hd__decap_3
XFILLER_11_295 VGND VGND VPWR VPWR sky130_fd_sc_hd__decap_3
XFILLER_7_255 VGND VGND VPWR VPWR sky130_fd_sc_hd__fill_1
XFILLER_7_266 VGND VGND VPWR VPWR sky130_fd_sc_hd__decap_3
XFILLER_109_161 VGND VGND VPWR VPWR sky130_fd_sc_hd__decap_3
XFILLER_109_172 VGND VGND VPWR VPWR sky130_fd_sc_hd__decap_3
XFILLER_7_299 VGND VGND VPWR VPWR sky130_fd_sc_hd__decap_3
XFILLER_98_505 VGND VGND VPWR VPWR sky130_fd_sc_hd__decap_3
XFILLER_112_315 VGND VGND VPWR VPWR sky130_fd_sc_hd__fill_2
XFILLER_59_80 VGND VGND VPWR VPWR sky130_fd_sc_hd__decap_3
XTAP_TAPCELL_ROW_111_1643 VGND VPWR sky130_fd_sc_hd__tapvpwrvgnd_1
XFILLER_78_251 VGND VGND VPWR VPWR sky130_fd_sc_hd__fill_1
XFILLER_39_638 VGND VGND VPWR VPWR sky130_fd_sc_hd__decap_3
XFILLER_19_351 VGND VGND VPWR VPWR sky130_fd_sc_hd__decap_3
XFILLER_47_671 VGND VGND VPWR VPWR sky130_fd_sc_hd__fill_1
XFILLER_47_682 VGND VGND VPWR VPWR sky130_fd_sc_hd__decap_3
XFILLER_53_107 VGND VGND VPWR VPWR sky130_fd_sc_hd__decap_3
XFILLER_75_90 VGND VGND VPWR VPWR sky130_fd_sc_hd__decap_3
XFILLER_81_438 VGND VGND VPWR VPWR sky130_fd_sc_hd__decap_3
XFILLER_93_287 VGND VGND VPWR VPWR sky130_fd_sc_hd__decap_3
XFILLER_46_192 VGND VGND VPWR VPWR sky130_fd_sc_hd__decap_3
XFILLER_62_641 VGND VGND VPWR VPWR sky130_fd_sc_hd__decap_3
XFILLER_81_449 VGND VGND VPWR VPWR sky130_fd_sc_hd__decap_3
X_6880_ _6942_/CLK _6880_/D VGND VGND VPWR VPWR _6880_/Q sky130_fd_sc_hd__dfxtp_2
XFILLER_34_354 VGND VGND VPWR VPWR sky130_fd_sc_hd__decap_3
XFILLER_34_365 VGND VGND VPWR VPWR sky130_fd_sc_hd__decap_3
XFILLER_34_376 VGND VGND VPWR VPWR sky130_fd_sc_hd__fill_2
XFILLER_61_140 VGND VGND VPWR VPWR sky130_fd_sc_hd__decap_3
XFILLER_62_663 VGND VGND VPWR VPWR sky130_fd_sc_hd__decap_3
XFILLER_15_590 VGND VGND VPWR VPWR sky130_fd_sc_hd__decap_3
XFILLER_62_696 VGND VGND VPWR VPWR sky130_fd_sc_hd__decap_3
X_4713_ _7008_/Q _4731_/B VGND VGND VPWR VPWR _7008_/D sky130_fd_sc_hd__xnor2_2
XFILLER_30_582 VGND VGND VPWR VPWR sky130_fd_sc_hd__decap_3
X_5693_ _7352_/Q _5693_/A1 _5737_/S VGND VGND VPWR VPWR _6696_/D sky130_fd_sc_hd__mux2_2
X_4644_ _4111_/B _4643_/Y _4633_/A _4109_/X VGND VGND VPWR VPWR _4644_/X sky130_fd_sc_hd__a211o_2
XFILLER_116_610 VGND VGND VPWR VPWR sky130_fd_sc_hd__decap_3
X_7363_ _7370_/CLK _7363_/D _6643_/Y VGND VGND VPWR VPWR _7363_/Q sky130_fd_sc_hd__dfrtp_2
Xhold701 _6798_/Q VGND VGND VPWR VPWR _6798_/D sky130_fd_sc_hd__dlygate4sd3_1
Xhold712 _6909_/Q VGND VGND VPWR VPWR _6909_/D sky130_fd_sc_hd__dlygate4sd3_1
X_4575_ _4575_/A _4593_/B VGND VGND VPWR VPWR _7293_/D sky130_fd_sc_hd__and2_2
XFILLER_116_643 VGND VGND VPWR VPWR sky130_fd_sc_hd__fill_1
XFILLER_116_654 VGND VGND VPWR VPWR sky130_fd_sc_hd__decap_3
XFILLER_89_505 VGND VGND VPWR VPWR sky130_fd_sc_hd__decap_3
X_7294_ _7360_/CLK _7294_/D _6574_/Y VGND VGND VPWR VPWR _7294_/Q sky130_fd_sc_hd__dfrtp_2
Xhold723 _6816_/Q VGND VGND VPWR VPWR _6816_/D sky130_fd_sc_hd__dlygate4sd3_1
Xhold734 _6839_/Q VGND VGND VPWR VPWR _6839_/D sky130_fd_sc_hd__dlygate4sd3_1
Xhold745 _6949_/Q VGND VGND VPWR VPWR _6949_/D sky130_fd_sc_hd__dlygate4sd3_1
X_6314_ _6625_/A VGND VGND VPWR VPWR _6314_/Y sky130_fd_sc_hd__inv_2
X_3526_ _4938_/A _5072_/A VGND VGND VPWR VPWR _5057_/A sky130_fd_sc_hd__nand2_2
XFILLER_115_164 VGND VGND VPWR VPWR sky130_fd_sc_hd__decap_3
XFILLER_116_687 VGND VGND VPWR VPWR sky130_fd_sc_hd__decap_3
Xhold756 _6925_/Q VGND VGND VPWR VPWR _6925_/D sky130_fd_sc_hd__dlygate4sd3_1
Xhold767 _6971_/Q VGND VGND VPWR VPWR _6971_/D sky130_fd_sc_hd__dlygate4sd3_1
Xhold778 _6844_/Q VGND VGND VPWR VPWR _6844_/D sky130_fd_sc_hd__dlygate4sd3_1
XFILLER_103_348 VGND VGND VPWR VPWR sky130_fd_sc_hd__decap_3
XFILLER_39_28 VGND VGND VPWR VPWR sky130_fd_sc_hd__decap_3
Xhold789 _6748_/Q VGND VGND VPWR VPWR _6748_/D sky130_fd_sc_hd__dlygate4sd3_1
X_3457_ _4394_/A _3449_/C _4327_/A _3456_/X VGND VGND VPWR VPWR _3506_/B sky130_fd_sc_hd__a22o_2
XFILLER_69_251 VGND VGND VPWR VPWR sky130_fd_sc_hd__fill_1
XFILLER_85_700 VGND VGND VPWR VPWR sky130_fd_sc_hd__decap_3
X_3388_ _3394_/A _3429_/B VGND VGND VPWR VPWR _3556_/A sky130_fd_sc_hd__nor2_2
XFILLER_111_381 VGND VGND VPWR VPWR sky130_fd_sc_hd__fill_2
XFILLER_69_284 VGND VGND VPWR VPWR sky130_fd_sc_hd__decap_3
XFILLER_84_221 VGND VGND VPWR VPWR sky130_fd_sc_hd__decap_3
XFILLER_97_582 VGND VGND VPWR VPWR sky130_fd_sc_hd__fill_2
XFILLER_29_159 VGND VGND VPWR VPWR sky130_fd_sc_hd__decap_3
XFILLER_45_608 VGND VGND VPWR VPWR sky130_fd_sc_hd__decap_3
X_5058_ _5072_/A _4330_/B _5056_/X _5057_/Y VGND VGND VPWR VPWR _5662_/B sky130_fd_sc_hd__a211o_2
XPHY_EDGE_ROW_2_Right_2 VGND VGND VPWR VPWR sky130_fd_sc_hd__decap_3
XFILLER_38_660 VGND VGND VPWR VPWR sky130_fd_sc_hd__decap_3
XFILLER_84_287 VGND VGND VPWR VPWR sky130_fd_sc_hd__decap_3
XFILLER_25_343 VGND VGND VPWR VPWR sky130_fd_sc_hd__decap_3
XFILLER_38_693 VGND VGND VPWR VPWR sky130_fd_sc_hd__decap_3
XFILLER_53_641 VGND VGND VPWR VPWR sky130_fd_sc_hd__decap_3
XFILLER_111_33 VGND VGND VPWR VPWR sky130_fd_sc_hd__decap_3
XFILLER_25_354 VGND VGND VPWR VPWR sky130_fd_sc_hd__decap_3
XFILLER_52_162 VGND VGND VPWR VPWR sky130_fd_sc_hd__decap_3
XFILLER_53_685 VGND VGND VPWR VPWR sky130_fd_sc_hd__decap_3
XFILLER_80_460 VGND VGND VPWR VPWR sky130_fd_sc_hd__decap_3
XFILLER_111_66 VGND VGND VPWR VPWR sky130_fd_sc_hd__decap_3
XPHY_EDGE_ROW_80_Left_200 VGND VGND VPWR VPWR sky130_fd_sc_hd__decap_3
XTAP_TAPCELL_ROW_23_544 VGND VPWR sky130_fd_sc_hd__tapvpwrvgnd_1
XFILLER_40_379 VGND VGND VPWR VPWR sky130_fd_sc_hd__decap_3
XTAP_TAPCELL_ROW_51_897 VGND VPWR sky130_fd_sc_hd__tapvpwrvgnd_1
XFILLER_107_610 VGND VGND VPWR VPWR sky130_fd_sc_hd__decap_3
XFILLER_107_632 VGND VGND VPWR VPWR sky130_fd_sc_hd__decap_3
XFILLER_112_3 VGND VGND VPWR VPWR sky130_fd_sc_hd__decap_3
XFILLER_106_131 VGND VGND VPWR VPWR sky130_fd_sc_hd__decap_3
XFILLER_107_665 VGND VGND VPWR VPWR sky130_fd_sc_hd__decap_3
XFILLER_107_676 VGND VGND VPWR VPWR sky130_fd_sc_hd__decap_3
XFILLER_20_85 VGND VGND VPWR VPWR sky130_fd_sc_hd__decap_3
XFILLER_106_197 VGND VGND VPWR VPWR sky130_fd_sc_hd__fill_2
XFILLER_0_464 VGND VGND VPWR VPWR sky130_fd_sc_hd__fill_2
XFILLER_0_486 VGND VGND VPWR VPWR sky130_fd_sc_hd__decap_3
XFILLER_36_619 VGND VGND VPWR VPWR sky130_fd_sc_hd__decap_3
XFILLER_75_243 VGND VGND VPWR VPWR sky130_fd_sc_hd__decap_3
XFILLER_91_703 VGND VGND VPWR VPWR sky130_fd_sc_hd__decap_3
XFILLER_29_671 VGND VGND VPWR VPWR sky130_fd_sc_hd__fill_1
XFILLER_29_682 VGND VGND VPWR VPWR sky130_fd_sc_hd__decap_3
XFILLER_35_107 VGND VGND VPWR VPWR sky130_fd_sc_hd__decap_3
XFILLER_63_416 VGND VGND VPWR VPWR sky130_fd_sc_hd__decap_3
XFILLER_75_265 VGND VGND VPWR VPWR sky130_fd_sc_hd__decap_3
XTAP_TAPCELL_ROW_59_997 VGND VPWR sky130_fd_sc_hd__tapvpwrvgnd_1
XFILLER_63_449 VGND VGND VPWR VPWR sky130_fd_sc_hd__fill_1
XFILLER_90_224 VGND VGND VPWR VPWR sky130_fd_sc_hd__decap_3
XFILLER_90_246 VGND VGND VPWR VPWR sky130_fd_sc_hd__decap_3
Xplace438 _3334_/Y VGND VGND VPWR VPWR _3339_/C1 sky130_fd_sc_hd__buf_2
Xplace427 _3864_/S VGND VGND VPWR VPWR _4832_/A sky130_fd_sc_hd__buf_2
Xplace416 _4267_/B1 VGND VGND VPWR VPWR _4436_/B1 sky130_fd_sc_hd__buf_2
Xplace405 _4417_/B1 VGND VGND VPWR VPWR _4434_/A2 sky130_fd_sc_hd__buf_2
XTAP_TAPCELL_ROW_3_291 VGND VPWR sky130_fd_sc_hd__tapvpwrvgnd_1
XFILLER_16_376 VGND VGND VPWR VPWR sky130_fd_sc_hd__fill_2
XFILLER_43_151 VGND VGND VPWR VPWR sky130_fd_sc_hd__fill_1
XFILLER_44_663 VGND VGND VPWR VPWR sky130_fd_sc_hd__decap_3
XFILLER_45_60 VGND VGND VPWR VPWR sky130_fd_sc_hd__decap_3
Xplace449 _5323_/S VGND VGND VPWR VPWR _5315_/S sky130_fd_sc_hd__buf_2
XFILLER_31_335 VGND VGND VPWR VPWR sky130_fd_sc_hd__fill_1
XFILLER_43_184 VGND VGND VPWR VPWR sky130_fd_sc_hd__fill_1
XFILLER_44_696 VGND VGND VPWR VPWR sky130_fd_sc_hd__decap_3
XFILLER_31_357 VGND VGND VPWR VPWR sky130_fd_sc_hd__decap_3
XFILLER_77_6 VGND VGND VPWR VPWR sky130_fd_sc_hd__fill_1
XFILLER_8_542 VGND VGND VPWR VPWR sky130_fd_sc_hd__decap_3
XANTENNA_3 _7353_/Q VGND VGND VPWR VPWR sky130_fd_sc_hd__diode_2
XFILLER_8_575 VGND VGND VPWR VPWR sky130_fd_sc_hd__decap_3
X_4360_ _5072_/B _5071_/B VGND VGND VPWR VPWR _5073_/A sky130_fd_sc_hd__nand2_2
X_3311_ _5118_/C _4696_/B _3340_/B VGND VGND VPWR VPWR _5671_/A sky130_fd_sc_hd__o21ai_2
XFILLER_113_635 VGND VGND VPWR VPWR sky130_fd_sc_hd__decap_3
X_4291_ _4612_/A _4612_/B VGND VGND VPWR VPWR _4292_/C sky130_fd_sc_hd__xnor2_2
XFILLER_113_668 VGND VGND VPWR VPWR sky130_fd_sc_hd__decap_3
XFILLER_113_679 VGND VGND VPWR VPWR sky130_fd_sc_hd__decap_3
XFILLER_67_700 VGND VGND VPWR VPWR sky130_fd_sc_hd__decap_3
XFILLER_98_368 VGND VGND VPWR VPWR sky130_fd_sc_hd__fill_1
XFILLER_98_379 VGND VGND VPWR VPWR sky130_fd_sc_hd__decap_3
XFILLER_112_189 VGND VGND VPWR VPWR sky130_fd_sc_hd__decap_3
XFILLER_39_424 VGND VGND VPWR VPWR sky130_fd_sc_hd__fill_1
XFILLER_79_571 VGND VGND VPWR VPWR sky130_fd_sc_hd__fill_2
XFILLER_66_221 VGND VGND VPWR VPWR sky130_fd_sc_hd__decap_3
XFILLER_54_405 VGND VGND VPWR VPWR sky130_fd_sc_hd__decap_3
XFILLER_54_427 VGND VGND VPWR VPWR sky130_fd_sc_hd__decap_3
XFILLER_26_129 VGND VGND VPWR VPWR sky130_fd_sc_hd__decap_3
XFILLER_35_641 VGND VGND VPWR VPWR sky130_fd_sc_hd__decap_3
X_6932_ _6944_/CLK _6932_/D VGND VGND VPWR VPWR _6932_/Q sky130_fd_sc_hd__dfxtp_2
XFILLER_62_460 VGND VGND VPWR VPWR sky130_fd_sc_hd__decap_3
XFILLER_81_279 VGND VGND VPWR VPWR sky130_fd_sc_hd__fill_1
X_6863_ clkload8/A _6863_/D VGND VGND VPWR VPWR _6863_/Q sky130_fd_sc_hd__dfxtp_2
XFILLER_22_324 VGND VGND VPWR VPWR sky130_fd_sc_hd__decap_3
XFILLER_34_162 VGND VGND VPWR VPWR sky130_fd_sc_hd__decap_3
XFILLER_34_184 VGND VGND VPWR VPWR sky130_fd_sc_hd__decap_3
XFILLER_35_685 VGND VGND VPWR VPWR sky130_fd_sc_hd__decap_3
XFILLER_50_611 VGND VGND VPWR VPWR sky130_fd_sc_hd__decap_3
XFILLER_22_346 VGND VGND VPWR VPWR sky130_fd_sc_hd__decap_3
XFILLER_50_666 VGND VGND VPWR VPWR sky130_fd_sc_hd__decap_3
X_6794_ _7189_/CLK _6794_/D VGND VGND VPWR VPWR _6794_/Q sky130_fd_sc_hd__dfxtp_2
XFILLER_50_699 VGND VGND VPWR VPWR sky130_fd_sc_hd__fill_1
XTAP_TAPCELL_ROW_20_514 VGND VPWR sky130_fd_sc_hd__tapvpwrvgnd_1
XTAP_TAPCELL_ROW_20_503 VGND VPWR sky130_fd_sc_hd__tapvpwrvgnd_1
X_5676_ _7344_/Q _5676_/A1 _5721_/S VGND VGND VPWR VPWR _6688_/D sky130_fd_sc_hd__mux2_2
X_4627_ _4627_/A VGND VGND VPWR VPWR _4627_/Y sky130_fd_sc_hd__inv_2
XFILLER_104_613 VGND VGND VPWR VPWR sky130_fd_sc_hd__decap_3
XFILLER_116_462 VGND VGND VPWR VPWR sky130_fd_sc_hd__fill_1
XFILLER_2_707 VGND VGND VPWR VPWR sky130_fd_sc_hd__decap_3
XFILLER_89_313 VGND VGND VPWR VPWR sky130_fd_sc_hd__decap_3
X_7346_ _7355_/CLK _7346_/D _6626_/Y VGND VGND VPWR VPWR _7346_/Q sky130_fd_sc_hd__dfrtp_2
XFILLER_104_657 VGND VGND VPWR VPWR sky130_fd_sc_hd__decap_3
XFILLER_106_11 VGND VGND VPWR VPWR sky130_fd_sc_hd__decap_3
XFILLER_116_495 VGND VGND VPWR VPWR sky130_fd_sc_hd__decap_3
XFILLER_1_228 VGND VGND VPWR VPWR sky130_fd_sc_hd__fill_2
XFILLER_1_239 VGND VGND VPWR VPWR sky130_fd_sc_hd__decap_3
X_7277_ _7372_/CLK _7277_/D _6557_/Y VGND VGND VPWR VPWR _7277_/Q sky130_fd_sc_hd__dfrtp_2
X_3509_ _5640_/B _3509_/B VGND VGND VPWR VPWR _3509_/Y sky130_fd_sc_hd__nor2_2
XFILLER_103_134 VGND VGND VPWR VPWR sky130_fd_sc_hd__decap_3
XFILLER_77_508 VGND VGND VPWR VPWR sky130_fd_sc_hd__decap_3
XFILLER_89_357 VGND VGND VPWR VPWR sky130_fd_sc_hd__fill_1
XFILLER_103_189 VGND VGND VPWR VPWR sky130_fd_sc_hd__decap_3
XFILLER_106_55 VGND VGND VPWR VPWR sky130_fd_sc_hd__decap_3
XFILLER_112_690 VGND VGND VPWR VPWR sky130_fd_sc_hd__decap_3
XFILLER_57_221 VGND VGND VPWR VPWR sky130_fd_sc_hd__decap_3
XFILLER_57_254 VGND VGND VPWR VPWR sky130_fd_sc_hd__decap_3
XFILLER_73_703 VGND VGND VPWR VPWR sky130_fd_sc_hd__decap_3
XFILLER_85_530 VGND VGND VPWR VPWR sky130_fd_sc_hd__decap_3
XFILLER_97_390 VGND VGND VPWR VPWR sky130_fd_sc_hd__fill_2
Xhold1220 _7380_/Q VGND VGND VPWR VPWR _3905_/A1 sky130_fd_sc_hd__dlygate4sd3_1
Xhold1231 _7173_/Q VGND VGND VPWR VPWR _5315_/A0 sky130_fd_sc_hd__dlygate4sd3_1
Xhold1242 _7159_/Q VGND VGND VPWR VPWR _5344_/A0 sky130_fd_sc_hd__dlygate4sd3_1
XFILLER_18_619 VGND VGND VPWR VPWR sky130_fd_sc_hd__decap_3
Xhold1253 _7154_/Q VGND VGND VPWR VPWR _5354_/A0 sky130_fd_sc_hd__dlygate4sd3_1
Xhold1264 _7134_/Q VGND VGND VPWR VPWR _5398_/A0 sky130_fd_sc_hd__dlygate4sd3_1
Xhold1275 _7182_/Q VGND VGND VPWR VPWR _5296_/A0 sky130_fd_sc_hd__dlygate4sd3_1
XTAP_TAPCELL_ROW_86_1328 VGND VPWR sky130_fd_sc_hd__tapvpwrvgnd_1
XTAP_TAPCELL_ROW_28_614 VGND VPWR sky130_fd_sc_hd__tapvpwrvgnd_1
XTAP_TAPCELL_ROW_28_603 VGND VPWR sky130_fd_sc_hd__tapvpwrvgnd_1
XFILLER_38_490 VGND VGND VPWR VPWR sky130_fd_sc_hd__decap_3
XFILLER_45_449 VGND VGND VPWR VPWR sky130_fd_sc_hd__decap_3
Xclkbuf_leaf_37_clk clkbuf_3_6__f_clk/X VGND VGND VPWR VPWR _7387_/CLK sky130_fd_sc_hd__clkbuf_16
Xhold1286 _7176_/Q VGND VGND VPWR VPWR _5308_/A0 sky130_fd_sc_hd__dlygate4sd3_1
Xhold1297 _7225_/Q VGND VGND VPWR VPWR _5207_/A sky130_fd_sc_hd__dlygate4sd3_1
XTAP_TAPCELL_ROW_86_1339 VGND VPWR sky130_fd_sc_hd__tapvpwrvgnd_1
XTAP_TAPCELL_ROW_56_956 VGND VPWR sky130_fd_sc_hd__tapvpwrvgnd_1
XFILLER_26_663 VGND VGND VPWR VPWR sky130_fd_sc_hd__decap_3
XFILLER_41_600 VGND VGND VPWR VPWR sky130_fd_sc_hd__decap_3
XFILLER_53_460 VGND VGND VPWR VPWR sky130_fd_sc_hd__fill_1
XFILLER_72_279 VGND VGND VPWR VPWR sky130_fd_sc_hd__decap_3
XTAP_TAPCELL_ROW_0_261 VGND VPWR sky130_fd_sc_hd__tapvpwrvgnd_1
XTAP_TAPCELL_ROW_0_250 VGND VPWR sky130_fd_sc_hd__tapvpwrvgnd_1
XFILLER_15_30 VGND VGND VPWR VPWR sky130_fd_sc_hd__decap_3
XFILLER_25_162 VGND VGND VPWR VPWR sky130_fd_sc_hd__decap_3
XFILLER_26_696 VGND VGND VPWR VPWR sky130_fd_sc_hd__decap_3
XFILLER_40_110 VGND VGND VPWR VPWR sky130_fd_sc_hd__decap_3
XFILLER_13_346 VGND VGND VPWR VPWR sky130_fd_sc_hd__fill_1
XFILLER_41_644 VGND VGND VPWR VPWR sky130_fd_sc_hd__decap_3
XFILLER_80_290 VGND VGND VPWR VPWR sky130_fd_sc_hd__fill_2
XFILLER_15_96 VGND VGND VPWR VPWR sky130_fd_sc_hd__decap_3
XFILLER_41_688 VGND VGND VPWR VPWR sky130_fd_sc_hd__decap_3
XFILLER_9_317 VGND VGND VPWR VPWR sky130_fd_sc_hd__decap_3
XFILLER_21_390 VGND VGND VPWR VPWR sky130_fd_sc_hd__fill_2
XFILLER_40_187 VGND VGND VPWR VPWR sky130_fd_sc_hd__decap_3
XFILLER_5_545 VGND VGND VPWR VPWR sky130_fd_sc_hd__decap_3
XTAP_TAPCELL_ROW_97_1468 VGND VPWR sky130_fd_sc_hd__tapvpwrvgnd_1
XFILLER_5_567 VGND VGND VPWR VPWR sky130_fd_sc_hd__decap_3
XFILLER_110_616 VGND VGND VPWR VPWR sky130_fd_sc_hd__decap_3
XFILLER_49_700 VGND VGND VPWR VPWR sky130_fd_sc_hd__decap_3
XFILLER_68_508 VGND VGND VPWR VPWR sky130_fd_sc_hd__decap_3
XTAP_TAPCELL_ROW_8_361 VGND VPWR sky130_fd_sc_hd__tapvpwrvgnd_1
XFILLER_0_261 VGND VGND VPWR VPWR sky130_fd_sc_hd__decap_3
XFILLER_48_210 VGND VGND VPWR VPWR sky130_fd_sc_hd__decap_3
XFILLER_48_243 VGND VGND VPWR VPWR sky130_fd_sc_hd__decap_3
XFILLER_48_265 VGND VGND VPWR VPWR sky130_fd_sc_hd__decap_3
XFILLER_17_641 VGND VGND VPWR VPWR sky130_fd_sc_hd__decap_3
XFILLER_36_438 VGND VGND VPWR VPWR sky130_fd_sc_hd__decap_3
XFILLER_63_213 VGND VGND VPWR VPWR sky130_fd_sc_hd__decap_3
Xclkbuf_leaf_28_clk clkload0/A VGND VGND VPWR VPWR _7357_/CLK sky130_fd_sc_hd__clkbuf_16
Xplace202 _3562_/B VGND VGND VPWR VPWR place202/X sky130_fd_sc_hd__buf_2
XFILLER_51_419 VGND VGND VPWR VPWR sky130_fd_sc_hd__fill_2
XFILLER_91_577 VGND VGND VPWR VPWR sky130_fd_sc_hd__decap_3
XFILLER_17_685 VGND VGND VPWR VPWR sky130_fd_sc_hd__decap_3
XFILLER_31_110 VGND VGND VPWR VPWR sky130_fd_sc_hd__fill_2
XFILLER_32_622 VGND VGND VPWR VPWR sky130_fd_sc_hd__decap_3
XFILLER_44_460 VGND VGND VPWR VPWR sky130_fd_sc_hd__fill_2
XFILLER_44_471 VGND VGND VPWR VPWR sky130_fd_sc_hd__decap_3
XTAP_TAPCELL_ROW_106_1586 VGND VPWR sky130_fd_sc_hd__tapvpwrvgnd_1
XFILLER_31_143 VGND VGND VPWR VPWR sky130_fd_sc_hd__fill_1
XFILLER_32_666 VGND VGND VPWR VPWR sky130_fd_sc_hd__decap_3
XFILLER_72_80 VGND VGND VPWR VPWR sky130_fd_sc_hd__decap_3
X_3860_ _3860_/A0 _3859_/X _3864_/S VGND VGND VPWR VPWR _7386_/D sky130_fd_sc_hd__mux2_2
XFILLER_32_699 VGND VGND VPWR VPWR sky130_fd_sc_hd__fill_1
X_3791_ _3775_/X _3790_/X _4770_/A1 VGND VGND VPWR VPWR _4961_/A sky130_fd_sc_hd__o21a_2
XFILLER_12_390 VGND VGND VPWR VPWR sky130_fd_sc_hd__decap_3
XFILLER_31_187 VGND VGND VPWR VPWR sky130_fd_sc_hd__decap_3
XFILLER_75_3 VGND VGND VPWR VPWR sky130_fd_sc_hd__decap_3
XFILLER_117_204 VGND VGND VPWR VPWR sky130_fd_sc_hd__decap_3
XFILLER_8_361 VGND VGND VPWR VPWR sky130_fd_sc_hd__decap_3
XFILLER_8_394 VGND VGND VPWR VPWR sky130_fd_sc_hd__fill_1
X_7200_ _7358_/CLK _7200_/D _6480_/Y VGND VGND VPWR VPWR _7200_/Q sky130_fd_sc_hd__dfrtp_2
X_4412_ _4788_/B _4412_/B VGND VGND VPWR VPWR _4413_/A sky130_fd_sc_hd__or2_2
Xoutput636 _6991_/Q VGND VGND VPWR VPWR pc_out[14] sky130_fd_sc_hd__clkdlybuf4s25_1
Xoutput625 _5640_/Y VGND VGND VPWR VPWR instruction_out[4] sky130_fd_sc_hd__clkdlybuf4s25_1
Xoutput614 _3417_/C VGND VGND VPWR VPWR instruction_out[21] sky130_fd_sc_hd__clkdlybuf4s25_1
Xoutput603 _5658_/C VGND VGND VPWR VPWR alu_result_out[9] sky130_fd_sc_hd__clkdlybuf4s25_1
X_5392_ _5392_/A0 _4945_/X _5402_/S VGND VGND VPWR VPWR _7137_/D sky130_fd_sc_hd__mux2_2
XFILLER_99_600 VGND VGND VPWR VPWR sky130_fd_sc_hd__fill_2
XFILLER_113_410 VGND VGND VPWR VPWR sky130_fd_sc_hd__fill_2
X_7131_ _7354_/CLK _7131_/D _6411_/Y VGND VGND VPWR VPWR _7131_/Q sky130_fd_sc_hd__dfrtp_2
Xoutput658 _3330_/A VGND VGND VPWR VPWR pc_out[5] sky130_fd_sc_hd__clkdlybuf4s25_1
Xoutput647 _7001_/Q VGND VGND VPWR VPWR pc_out[24] sky130_fd_sc_hd__clkdlybuf4s25_1
X_4343_ _4365_/C _4365_/A _4365_/B VGND VGND VPWR VPWR _4343_/X sky130_fd_sc_hd__and3b_2
XPHY_EDGE_ROW_99_Right_99 VGND VGND VPWR VPWR sky130_fd_sc_hd__decap_3
XFILLER_99_644 VGND VGND VPWR VPWR sky130_fd_sc_hd__decap_3
XFILLER_113_443 VGND VGND VPWR VPWR sky130_fd_sc_hd__decap_3
XFILLER_59_508 VGND VGND VPWR VPWR sky130_fd_sc_hd__decap_3
XFILLER_98_132 VGND VGND VPWR VPWR sky130_fd_sc_hd__decap_3
X_7062_ _7345_/CLK _7062_/D _6342_/Y VGND VGND VPWR VPWR _7062_/Q sky130_fd_sc_hd__dfrtp_2
X_4274_ _4376_/A _4376_/B _4376_/C _4273_/D VGND VGND VPWR VPWR _4274_/Y sky130_fd_sc_hd__o31ai_2
XTAP_TAPCELL_ROW_70_1129 VGND VPWR sky130_fd_sc_hd__tapvpwrvgnd_1
XFILLER_99_688 VGND VGND VPWR VPWR sky130_fd_sc_hd__decap_3
XFILLER_101_638 VGND VGND VPWR VPWR sky130_fd_sc_hd__decap_3
XFILLER_100_137 VGND VGND VPWR VPWR sky130_fd_sc_hd__decap_3
XFILLER_100_159 VGND VGND VPWR VPWR sky130_fd_sc_hd__decap_3
XFILLER_39_243 VGND VGND VPWR VPWR sky130_fd_sc_hd__decap_3
XFILLER_55_703 VGND VGND VPWR VPWR sky130_fd_sc_hd__decap_3
XFILLER_67_585 VGND VGND VPWR VPWR sky130_fd_sc_hd__fill_2
XFILLER_27_449 VGND VGND VPWR VPWR sky130_fd_sc_hd__decap_3
XFILLER_39_287 VGND VGND VPWR VPWR sky130_fd_sc_hd__decap_3
XFILLER_54_224 VGND VGND VPWR VPWR sky130_fd_sc_hd__decap_3
XFILLER_82_522 VGND VGND VPWR VPWR sky130_fd_sc_hd__decap_3
XFILLER_82_533 VGND VGND VPWR VPWR sky130_fd_sc_hd__decap_3
Xclkbuf_leaf_19_clk clkload2/A VGND VGND VPWR VPWR _7372_/CLK sky130_fd_sc_hd__clkbuf_16
XFILLER_54_268 VGND VGND VPWR VPWR sky130_fd_sc_hd__decap_3
X_6915_ _6923_/CLK _6915_/D VGND VGND VPWR VPWR _6915_/Q sky130_fd_sc_hd__dfxtp_2
XTAP_TAPCELL_ROW_53_915 VGND VPWR sky130_fd_sc_hd__tapvpwrvgnd_1
XFILLER_23_600 VGND VGND VPWR VPWR sky130_fd_sc_hd__decap_3
XTAP_TAPCELL_ROW_53_926 VGND VPWR sky130_fd_sc_hd__tapvpwrvgnd_1
XFILLER_23_644 VGND VGND VPWR VPWR sky130_fd_sc_hd__decap_3
XFILLER_52_39 VGND VGND VPWR VPWR sky130_fd_sc_hd__decap_3
X_6846_ clkload8/A _6846_/D VGND VGND VPWR VPWR _6846_/Q sky130_fd_sc_hd__dfxtp_2
XFILLER_23_688 VGND VGND VPWR VPWR sky130_fd_sc_hd__decap_3
X_6777_ _6944_/CLK _6777_/D VGND VGND VPWR VPWR _6777_/Q sky130_fd_sc_hd__dfxtp_2
XTAP_TAPCELL_ROW_81_1269 VGND VPWR sky130_fd_sc_hd__tapvpwrvgnd_1
XTAP_TAPCELL_ROW_33_672 VGND VPWR sky130_fd_sc_hd__tapvpwrvgnd_1
XFILLER_10_349 VGND VGND VPWR VPWR sky130_fd_sc_hd__decap_3
X_3989_ _7346_/Q _4530_/A0 _3996_/S VGND VGND VPWR VPWR _7346_/D sky130_fd_sc_hd__mux2_2
XFILLER_108_215 VGND VGND VPWR VPWR sky130_fd_sc_hd__decap_3
XFILLER_6_309 VGND VGND VPWR VPWR sky130_fd_sc_hd__decap_3
XFILLER_108_248 VGND VGND VPWR VPWR sky130_fd_sc_hd__decap_3
XFILLER_108_259 VGND VGND VPWR VPWR sky130_fd_sc_hd__decap_3
X_5659_ _5659_/A _5659_/B VGND VGND VPWR VPWR _5660_/D sky130_fd_sc_hd__nor2_2
XFILLER_2_504 VGND VGND VPWR VPWR sky130_fd_sc_hd__decap_3
XFILLER_104_421 VGND VGND VPWR VPWR sky130_fd_sc_hd__decap_3
XFILLER_116_270 VGND VGND VPWR VPWR sky130_fd_sc_hd__decap_3
XFILLER_117_32 VGND VGND VPWR VPWR sky130_fd_sc_hd__decap_3
XFILLER_2_548 VGND VGND VPWR VPWR sky130_fd_sc_hd__decap_3
X_7329_ _7370_/CLK _7329_/D _6609_/Y VGND VGND VPWR VPWR _7329_/Q sky130_fd_sc_hd__dfrtp_2
XFILLER_104_465 VGND VGND VPWR VPWR sky130_fd_sc_hd__decap_3
XFILLER_117_87 VGND VGND VPWR VPWR sky130_fd_sc_hd__decap_3
XFILLER_77_36 VGND VGND VPWR VPWR sky130_fd_sc_hd__decap_3
XFILLER_89_143 VGND VGND VPWR VPWR sky130_fd_sc_hd__decap_3
XFILLER_104_498 VGND VGND VPWR VPWR sky130_fd_sc_hd__decap_3
XFILLER_89_187 VGND VGND VPWR VPWR sky130_fd_sc_hd__decap_3
XTAP_TAPCELL_ROW_5_320 VGND VPWR sky130_fd_sc_hd__tapvpwrvgnd_1
XFILLER_77_349 VGND VGND VPWR VPWR sky130_fd_sc_hd__decap_3
XFILLER_100_660 VGND VGND VPWR VPWR sky130_fd_sc_hd__decap_3
XFILLER_18_416 VGND VGND VPWR VPWR sky130_fd_sc_hd__decap_3
XFILLER_73_500 VGND VGND VPWR VPWR sky130_fd_sc_hd__decap_3
Xhold1050 _6710_/Q VGND VGND VPWR VPWR _5721_/A1 sky130_fd_sc_hd__dlygate4sd3_1
XFILLER_100_693 VGND VGND VPWR VPWR sky130_fd_sc_hd__decap_3
XFILLER_18_427 VGND VGND VPWR VPWR sky130_fd_sc_hd__decap_3
XFILLER_18_438 VGND VGND VPWR VPWR sky130_fd_sc_hd__fill_1
XFILLER_85_382 VGND VGND VPWR VPWR sky130_fd_sc_hd__decap_3
XFILLER_85_393 VGND VGND VPWR VPWR sky130_fd_sc_hd__decap_3
Xhold1061 _7047_/Q VGND VGND VPWR VPWR _5570_/A1 sky130_fd_sc_hd__dlygate4sd3_1
Xhold1072 _7406_/Q VGND VGND VPWR VPWR _3645_/A1 sky130_fd_sc_hd__dlygate4sd3_1
Xhold1083 _5688_/X VGND VGND VPWR VPWR _6694_/D sky130_fd_sc_hd__dlygate4sd3_1
Xhold1094 _7275_/Q VGND VGND VPWR VPWR _4772_/A0 sky130_fd_sc_hd__dlygate4sd3_1
XFILLER_61_706 VGND VGND VPWR VPWR sky130_fd_sc_hd__decap_3
XFILLER_14_622 VGND VGND VPWR VPWR sky130_fd_sc_hd__decap_3
XFILLER_73_588 VGND VGND VPWR VPWR sky130_fd_sc_hd__decap_3
XFILLER_13_110 VGND VGND VPWR VPWR sky130_fd_sc_hd__fill_2
XFILLER_14_666 VGND VGND VPWR VPWR sky130_fd_sc_hd__decap_3
XFILLER_53_290 VGND VGND VPWR VPWR sky130_fd_sc_hd__fill_1
XFILLER_14_699 VGND VGND VPWR VPWR sky130_fd_sc_hd__fill_1
XFILLER_41_452 VGND VGND VPWR VPWR sky130_fd_sc_hd__decap_3
XFILLER_9_169 VGND VGND VPWR VPWR sky130_fd_sc_hd__decap_3
XFILLER_5_320 VGND VGND VPWR VPWR sky130_fd_sc_hd__decap_3
XTAP_TAPCELL_ROW_11_399 VGND VPWR sky130_fd_sc_hd__tapvpwrvgnd_1
XFILLER_5_364 VGND VGND VPWR VPWR sky130_fd_sc_hd__decap_3
XFILLER_107_281 VGND VGND VPWR VPWR sky130_fd_sc_hd__decap_3
XFILLER_5_386 VGND VGND VPWR VPWR sky130_fd_sc_hd__decap_3
XFILLER_1_570 VGND VGND VPWR VPWR sky130_fd_sc_hd__decap_3
XFILLER_68_316 VGND VGND VPWR VPWR sky130_fd_sc_hd__decap_3
XFILLER_95_113 VGND VGND VPWR VPWR sky130_fd_sc_hd__decap_3
XFILLER_96_625 VGND VGND VPWR VPWR sky130_fd_sc_hd__decap_3
XFILLER_95_146 VGND VGND VPWR VPWR sky130_fd_sc_hd__decap_3
XFILLER_96_669 VGND VGND VPWR VPWR sky130_fd_sc_hd__decap_3
XFILLER_37_703 VGND VGND VPWR VPWR sky130_fd_sc_hd__decap_3
XFILLER_76_360 VGND VGND VPWR VPWR sky130_fd_sc_hd__decap_3
XTAP_TAPCELL_ROW_108_1604 VGND VPWR sky130_fd_sc_hd__tapvpwrvgnd_1
XFILLER_36_224 VGND VGND VPWR VPWR sky130_fd_sc_hd__decap_3
XFILLER_64_522 VGND VGND VPWR VPWR sky130_fd_sc_hd__decap_3
XFILLER_64_533 VGND VGND VPWR VPWR sky130_fd_sc_hd__decap_3
XFILLER_64_544 VGND VGND VPWR VPWR sky130_fd_sc_hd__decap_3
XFILLER_91_330 VGND VGND VPWR VPWR sky130_fd_sc_hd__decap_3
XFILLER_36_246 VGND VGND VPWR VPWR sky130_fd_sc_hd__decap_3
XFILLER_91_363 VGND VGND VPWR VPWR sky130_fd_sc_hd__decap_3
XFILLER_17_471 VGND VGND VPWR VPWR sky130_fd_sc_hd__decap_3
XFILLER_36_279 VGND VGND VPWR VPWR sky130_fd_sc_hd__decap_3
XFILLER_51_205 VGND VGND VPWR VPWR sky130_fd_sc_hd__decap_3
X_4961_ _4961_/A _5662_/C _4961_/C VGND VGND VPWR VPWR _4961_/X sky130_fd_sc_hd__or3_4
XTAP_TAPCELL_ROW_19_499 VGND VPWR sky130_fd_sc_hd__tapvpwrvgnd_1
XFILLER_51_249 VGND VGND VPWR VPWR sky130_fd_sc_hd__decap_3
XFILLER_83_90 VGND VGND VPWR VPWR sky130_fd_sc_hd__decap_3
X_6700_ _6922_/CLK _6700_/D VGND VGND VPWR VPWR _6700_/Q sky130_fd_sc_hd__dfxtp_2
X_4892_ _4884_/X _4886_/X _4887_/Y _4891_/X VGND VGND VPWR VPWR _5656_/B sky130_fd_sc_hd__a31o_2
X_3912_ _6905_/Q _3912_/A2 _3912_/B1 _6897_/Q VGND VGND VPWR VPWR _3912_/X sky130_fd_sc_hd__a22o_2
XTAP_TAPCELL_ROW_67_1091 VGND VPWR sky130_fd_sc_hd__tapvpwrvgnd_1
XFILLER_20_625 VGND VGND VPWR VPWR sky130_fd_sc_hd__decap_3
XFILLER_32_463 VGND VGND VPWR VPWR sky130_fd_sc_hd__decap_3
X_6631_ _6631_/A VGND VGND VPWR VPWR _6631_/Y sky130_fd_sc_hd__inv_2
X_3843_ _6699_/Q _3887_/A2 _3887_/B1 _6877_/Q _3842_/X VGND VGND VPWR VPWR _3843_/X
+ sky130_fd_sc_hd__a221o_2
XTAP_TAPCELL_ROW_30_631 VGND VPWR sky130_fd_sc_hd__tapvpwrvgnd_1
XFILLER_20_669 VGND VGND VPWR VPWR sky130_fd_sc_hd__decap_3
X_6562_ _6635_/A VGND VGND VPWR VPWR _6562_/Y sky130_fd_sc_hd__inv_2
X_3774_ _6757_/Q _3913_/B1 _3912_/B1 _6769_/Q _3773_/X VGND VGND VPWR VPWR _3774_/X
+ sky130_fd_sc_hd__a221o_2
XTAP_TAPCELL_ROW_119_1744 VGND VPWR sky130_fd_sc_hd__tapvpwrvgnd_1
X_6493_ _6652_/A VGND VGND VPWR VPWR _6493_/Y sky130_fd_sc_hd__inv_2
XTAP_TAPCELL_ROW_119_1755 VGND VPWR sky130_fd_sc_hd__tapvpwrvgnd_1
Xclkbuf_leaf_8_clk clkbuf_leaf_9_clk/A VGND VGND VPWR VPWR _6944_/CLK sky130_fd_sc_hd__clkbuf_16
XFILLER_99_430 VGND VGND VPWR VPWR sky130_fd_sc_hd__decap_3
X_7114_ _7342_/CLK _7114_/D _6394_/Y VGND VGND VPWR VPWR _7114_/Q sky130_fd_sc_hd__dfrtp_2
X_5375_ _5375_/A0 _4806_/X _5379_/S VGND VGND VPWR VPWR _7145_/D sky130_fd_sc_hd__mux2_2
XFILLER_99_452 VGND VGND VPWR VPWR sky130_fd_sc_hd__decap_3
XFILLER_87_625 VGND VGND VPWR VPWR sky130_fd_sc_hd__decap_3
X_4326_ _7013_/Q _4356_/A2 _4322_/X _4325_/X VGND VGND VPWR VPWR _4327_/B sky130_fd_sc_hd__a211o_2
XFILLER_101_457 VGND VGND VPWR VPWR sky130_fd_sc_hd__decap_3
XFILLER_86_135 VGND VGND VPWR VPWR sky130_fd_sc_hd__decap_3
XFILLER_87_658 VGND VGND VPWR VPWR sky130_fd_sc_hd__decap_3
X_7045_ _7358_/CLK _7045_/D _6325_/Y VGND VGND VPWR VPWR _7045_/Q sky130_fd_sc_hd__dfrtp_2
X_4257_ _4626_/B _4626_/C _4256_/C VGND VGND VPWR VPWR _4988_/B sky130_fd_sc_hd__a21oi_2
XFILLER_101_479 VGND VGND VPWR VPWR sky130_fd_sc_hd__decap_3
XFILLER_67_360 VGND VGND VPWR VPWR sky130_fd_sc_hd__fill_2
XFILLER_86_168 VGND VGND VPWR VPWR sky130_fd_sc_hd__fill_1
X_4188_ _7359_/Q _4338_/B1 _4187_/X _4248_/A VGND VGND VPWR VPWR _4188_/X sky130_fd_sc_hd__a211o_2
XFILLER_27_213 VGND VGND VPWR VPWR sky130_fd_sc_hd__decap_3
XFILLER_67_393 VGND VGND VPWR VPWR sky130_fd_sc_hd__decap_3
XFILLER_95_691 VGND VGND VPWR VPWR sky130_fd_sc_hd__decap_3
XTAP_TAPCELL_ROW_38_731 VGND VPWR sky130_fd_sc_hd__tapvpwrvgnd_1
XFILLER_27_246 VGND VGND VPWR VPWR sky130_fd_sc_hd__decap_3
XFILLER_43_706 VGND VGND VPWR VPWR sky130_fd_sc_hd__decap_3
XFILLER_55_577 VGND VGND VPWR VPWR sky130_fd_sc_hd__decap_3
XFILLER_70_503 VGND VGND VPWR VPWR sky130_fd_sc_hd__decap_3
XFILLER_94_190 VGND VGND VPWR VPWR sky130_fd_sc_hd__decap_3
XFILLER_15_419 VGND VGND VPWR VPWR sky130_fd_sc_hd__decap_3
XFILLER_27_279 VGND VGND VPWR VPWR sky130_fd_sc_hd__fill_1
XFILLER_11_603 VGND VGND VPWR VPWR sky130_fd_sc_hd__decap_3
XFILLER_23_463 VGND VGND VPWR VPWR sky130_fd_sc_hd__decap_3
X_6829_ clkload8/A _6829_/D VGND VGND VPWR VPWR _6829_/Q sky130_fd_sc_hd__dfxtp_2
XFILLER_11_647 VGND VGND VPWR VPWR sky130_fd_sc_hd__decap_3
XFILLER_50_293 VGND VGND VPWR VPWR sky130_fd_sc_hd__decap_3
XFILLER_10_157 VGND VGND VPWR VPWR sky130_fd_sc_hd__fill_1
XFILLER_7_629 VGND VGND VPWR VPWR sky130_fd_sc_hd__decap_3
XFILLER_12_53 VGND VGND VPWR VPWR sky130_fd_sc_hd__decap_3
XTAP_TAPCELL_ROW_94_1438 VGND VPWR sky130_fd_sc_hd__tapvpwrvgnd_1
XTAP_TAPCELL_ROW_94_1427 VGND VPWR sky130_fd_sc_hd__tapvpwrvgnd_1
XFILLER_2_312 VGND VGND VPWR VPWR sky130_fd_sc_hd__decap_3
XFILLER_2_323 VGND VGND VPWR VPWR sky130_fd_sc_hd__decap_3
XFILLER_88_46 VGND VGND VPWR VPWR sky130_fd_sc_hd__decap_3
XFILLER_2_356 VGND VGND VPWR VPWR sky130_fd_sc_hd__decap_3
XFILLER_88_79 VGND VGND VPWR VPWR sky130_fd_sc_hd__decap_3
XFILLER_104_251 VGND VGND VPWR VPWR sky130_fd_sc_hd__fill_1
XFILLER_104_262 VGND VGND VPWR VPWR sky130_fd_sc_hd__decap_3
XFILLER_77_113 VGND VGND VPWR VPWR sky130_fd_sc_hd__decap_3
XFILLER_78_669 VGND VGND VPWR VPWR sky130_fd_sc_hd__decap_3
XFILLER_19_703 VGND VGND VPWR VPWR sky130_fd_sc_hd__decap_3
XFILLER_65_319 VGND VGND VPWR VPWR sky130_fd_sc_hd__decap_3
XFILLER_77_157 VGND VGND VPWR VPWR sky130_fd_sc_hd__decap_3
XFILLER_93_617 VGND VGND VPWR VPWR sky130_fd_sc_hd__decap_3
XFILLER_58_371 VGND VGND VPWR VPWR sky130_fd_sc_hd__decap_3
XFILLER_58_393 VGND VGND VPWR VPWR sky130_fd_sc_hd__decap_3
XFILLER_92_127 VGND VGND VPWR VPWR sky130_fd_sc_hd__decap_3
XFILLER_18_246 VGND VGND VPWR VPWR sky130_fd_sc_hd__decap_3
XFILLER_33_216 VGND VGND VPWR VPWR sky130_fd_sc_hd__decap_3
XFILLER_61_525 VGND VGND VPWR VPWR sky130_fd_sc_hd__decap_3
XFILLER_73_374 VGND VGND VPWR VPWR sky130_fd_sc_hd__decap_3
XFILLER_14_430 VGND VGND VPWR VPWR sky130_fd_sc_hd__decap_3
XFILLER_26_290 VGND VGND VPWR VPWR sky130_fd_sc_hd__decap_3
XTAP_TAPCELL_ROW_103_1545 VGND VPWR sky130_fd_sc_hd__tapvpwrvgnd_1
XFILLER_14_463 VGND VGND VPWR VPWR sky130_fd_sc_hd__decap_3
XTAP_TAPCELL_ROW_16_458 VGND VPWR sky130_fd_sc_hd__tapvpwrvgnd_1
XFILLER_115_505 VGND VGND VPWR VPWR sky130_fd_sc_hd__decap_3
XFILLER_6_640 VGND VGND VPWR VPWR sky130_fd_sc_hd__decap_3
XFILLER_6_651 VGND VGND VPWR VPWR sky130_fd_sc_hd__decap_3
X_3490_ _7119_/Q _5229_/C _3489_/X _4347_/C1 VGND VGND VPWR VPWR _3490_/X sky130_fd_sc_hd__a211o_2
XFILLER_115_527 VGND VGND VPWR VPWR sky130_fd_sc_hd__decap_3
XFILLER_6_684 VGND VGND VPWR VPWR sky130_fd_sc_hd__decap_3
XFILLER_111_700 VGND VGND VPWR VPWR sky130_fd_sc_hd__decap_3
XFILLER_38_3 VGND VGND VPWR VPWR sky130_fd_sc_hd__fill_1
XTAP_TAPCELL_ROW_114_1685 VGND VPWR sky130_fd_sc_hd__tapvpwrvgnd_1
XFILLER_110_232 VGND VGND VPWR VPWR sky130_fd_sc_hd__decap_3
XFILLER_69_647 VGND VGND VPWR VPWR sky130_fd_sc_hd__decap_3
X_5091_ _6985_/Q _5068_/C _6986_/Q VGND VGND VPWR VPWR _5092_/B sky130_fd_sc_hd__a21o_2
X_4111_ _4109_/X _4111_/B VGND VGND VPWR VPWR _4845_/A sky130_fd_sc_hd__nand2b_2
XFILLER_110_265 VGND VGND VPWR VPWR sky130_fd_sc_hd__decap_3
XFILLER_37_500 VGND VGND VPWR VPWR sky130_fd_sc_hd__decap_3
XFILLER_68_168 VGND VGND VPWR VPWR sky130_fd_sc_hd__decap_3
XFILLER_84_628 VGND VGND VPWR VPWR sky130_fd_sc_hd__decap_3
XFILLER_96_466 VGND VGND VPWR VPWR sky130_fd_sc_hd__fill_1
XFILLER_96_477 VGND VGND VPWR VPWR sky130_fd_sc_hd__fill_2
X_4042_ _7341_/Q _3954_/S _4419_/B1 _7373_/Q _4429_/C1 VGND VGND VPWR VPWR _4042_/X
+ sky130_fd_sc_hd__a221o_2
XFILLER_110_287 VGND VGND VPWR VPWR sky130_fd_sc_hd__decap_3
XFILLER_37_511 VGND VGND VPWR VPWR sky130_fd_sc_hd__fill_2
XFILLER_49_393 VGND VGND VPWR VPWR sky130_fd_sc_hd__decap_3
XFILLER_77_691 VGND VGND VPWR VPWR sky130_fd_sc_hd__decap_3
XFILLER_83_116 VGND VGND VPWR VPWR sky130_fd_sc_hd__decap_3
XFILLER_83_138 VGND VGND VPWR VPWR sky130_fd_sc_hd__decap_3
XTAP_TAPCELL_ROW_69_1120 VGND VPWR sky130_fd_sc_hd__tapvpwrvgnd_1
XFILLER_25_706 VGND VGND VPWR VPWR sky130_fd_sc_hd__decap_3
XFILLER_24_227 VGND VGND VPWR VPWR sky130_fd_sc_hd__decap_3
XFILLER_37_599 VGND VGND VPWR VPWR sky130_fd_sc_hd__decap_3
XFILLER_64_374 VGND VGND VPWR VPWR sky130_fd_sc_hd__fill_2
XFILLER_91_160 VGND VGND VPWR VPWR sky130_fd_sc_hd__decap_3
XFILLER_92_672 VGND VGND VPWR VPWR sky130_fd_sc_hd__decap_3
XTAP_TAPCELL_ROW_35_701 VGND VPWR sky130_fd_sc_hd__tapvpwrvgnd_1
XFILLER_91_193 VGND VGND VPWR VPWR sky130_fd_sc_hd__decap_3
X_4944_ _5010_/A _4944_/B _4944_/C VGND VGND VPWR VPWR _4944_/X sky130_fd_sc_hd__or3_2
XFILLER_20_433 VGND VGND VPWR VPWR sky130_fd_sc_hd__decap_3
XFILLER_32_293 VGND VGND VPWR VPWR sky130_fd_sc_hd__decap_3
X_4875_ _4842_/X _4871_/Y _4874_/X VGND VGND VPWR VPWR _5663_/C sky130_fd_sc_hd__a21bo_2
X_6614_ _6645_/A VGND VGND VPWR VPWR _6614_/Y sky130_fd_sc_hd__inv_2
X_3826_ _6731_/Q _3913_/B1 _3912_/B1 _6743_/Q _3825_/X VGND VGND VPWR VPWR _3826_/X
+ sky130_fd_sc_hd__a221o_2
XFILLER_118_332 VGND VGND VPWR VPWR sky130_fd_sc_hd__decap_3
X_6545_ _6680_/A VGND VGND VPWR VPWR _6545_/Y sky130_fd_sc_hd__inv_2
X_3757_ _3757_/A0 _3756_/X _4799_/A VGND VGND VPWR VPWR _7396_/D sky130_fd_sc_hd__mux2_2
XFILLER_109_9 VGND VGND VPWR VPWR sky130_fd_sc_hd__decap_3
X_6476_ _6667_/A VGND VGND VPWR VPWR _6476_/Y sky130_fd_sc_hd__inv_2
X_5427_ _5427_/A0 _5156_/X _5427_/S VGND VGND VPWR VPWR _7120_/D sky130_fd_sc_hd__mux2_2
XFILLER_114_582 VGND VGND VPWR VPWR sky130_fd_sc_hd__decap_3
X_5358_ _5358_/A0 _5156_/X _7412_/A VGND VGND VPWR VPWR _7152_/D sky130_fd_sc_hd__mux2_2
XFILLER_99_260 VGND VGND VPWR VPWR sky130_fd_sc_hd__decap_3
XFILLER_101_221 VGND VGND VPWR VPWR sky130_fd_sc_hd__decap_3
XFILLER_59_113 VGND VGND VPWR VPWR sky130_fd_sc_hd__decap_3
XFILLER_59_146 VGND VGND VPWR VPWR sky130_fd_sc_hd__decap_3
XFILLER_87_422 VGND VGND VPWR VPWR sky130_fd_sc_hd__decap_3
XFILLER_87_455 VGND VGND VPWR VPWR sky130_fd_sc_hd__decap_3
X_4309_ _7128_/Q _4333_/A2 _4307_/X _4308_/X VGND VGND VPWR VPWR _4311_/B sky130_fd_sc_hd__a211o_2
XFILLER_114_11 VGND VGND VPWR VPWR sky130_fd_sc_hd__decap_3
XFILLER_75_617 VGND VGND VPWR VPWR sky130_fd_sc_hd__decap_3
XFILLER_87_488 VGND VGND VPWR VPWR sky130_fd_sc_hd__fill_1
X_7028_ _7388_/CLK _7028_/D _6308_/Y VGND VGND VPWR VPWR _7028_/Q sky130_fd_sc_hd__dfrtp_2
XFILLER_101_276 VGND VGND VPWR VPWR sky130_fd_sc_hd__decap_3
XFILLER_101_298 VGND VGND VPWR VPWR sky130_fd_sc_hd__decap_3
XFILLER_114_44 VGND VGND VPWR VPWR sky130_fd_sc_hd__decap_3
XFILLER_28_511 VGND VGND VPWR VPWR sky130_fd_sc_hd__decap_3
XFILLER_28_533 VGND VGND VPWR VPWR sky130_fd_sc_hd__decap_3
XFILLER_74_127 VGND VGND VPWR VPWR sky130_fd_sc_hd__decap_3
XFILLER_114_77 VGND VGND VPWR VPWR sky130_fd_sc_hd__decap_3
XFILLER_114_88 VGND VGND VPWR VPWR sky130_fd_sc_hd__decap_3
XFILLER_55_352 VGND VGND VPWR VPWR sky130_fd_sc_hd__fill_2
XFILLER_74_59 VGND VGND VPWR VPWR sky130_fd_sc_hd__decap_3
XFILLER_83_650 VGND VGND VPWR VPWR sky130_fd_sc_hd__decap_3
XFILLER_43_525 VGND VGND VPWR VPWR sky130_fd_sc_hd__decap_3
XFILLER_83_694 VGND VGND VPWR VPWR sky130_fd_sc_hd__decap_3
XFILLER_31_709 VGND VGND VPWR VPWR sky130_fd_sc_hd__decap_3
XFILLER_70_333 VGND VGND VPWR VPWR sky130_fd_sc_hd__decap_3
XFILLER_70_377 VGND VGND VPWR VPWR sky130_fd_sc_hd__fill_2
XTAP_TAPCELL_ROW_13_417 VGND VPWR sky130_fd_sc_hd__tapvpwrvgnd_1
XFILLER_23_293 VGND VGND VPWR VPWR sky130_fd_sc_hd__fill_1
XFILLER_109_321 VGND VGND VPWR VPWR sky130_fd_sc_hd__fill_2
XFILLER_11_488 VGND VGND VPWR VPWR sky130_fd_sc_hd__fill_1
XFILLER_23_74 VGND VGND VPWR VPWR sky130_fd_sc_hd__fill_2
XFILLER_7_437 VGND VGND VPWR VPWR sky130_fd_sc_hd__decap_3
XFILLER_99_23 VGND VGND VPWR VPWR sky130_fd_sc_hd__fill_1
XFILLER_3_610 VGND VGND VPWR VPWR sky130_fd_sc_hd__decap_3
XFILLER_112_508 VGND VGND VPWR VPWR sky130_fd_sc_hd__decap_3
XFILLER_3_632 VGND VGND VPWR VPWR sky130_fd_sc_hd__decap_3
XFILLER_3_665 VGND VGND VPWR VPWR sky130_fd_sc_hd__decap_3
XFILLER_3_676 VGND VGND VPWR VPWR sky130_fd_sc_hd__decap_3
XFILLER_97_219 VGND VGND VPWR VPWR sky130_fd_sc_hd__decap_3
XFILLER_2_175 VGND VGND VPWR VPWR sky130_fd_sc_hd__decap_3
XFILLER_2_197 VGND VGND VPWR VPWR sky130_fd_sc_hd__decap_3
XFILLER_78_433 VGND VGND VPWR VPWR sky130_fd_sc_hd__fill_1
XFILLER_65_105 VGND VGND VPWR VPWR sky130_fd_sc_hd__decap_3
XFILLER_66_617 VGND VGND VPWR VPWR sky130_fd_sc_hd__decap_3
XFILLER_19_500 VGND VGND VPWR VPWR sky130_fd_sc_hd__decap_3
XFILLER_48_82 VGND VGND VPWR VPWR sky130_fd_sc_hd__fill_2
XFILLER_48_93 VGND VGND VPWR VPWR sky130_fd_sc_hd__fill_1
XFILLER_59_691 VGND VGND VPWR VPWR sky130_fd_sc_hd__decap_3
XFILLER_65_116 VGND VGND VPWR VPWR sky130_fd_sc_hd__decap_3
XFILLER_65_149 VGND VGND VPWR VPWR sky130_fd_sc_hd__decap_3
XPHY_EDGE_ROW_100_Left_220 VGND VGND VPWR VPWR sky130_fd_sc_hd__decap_3
XFILLER_19_577 VGND VGND VPWR VPWR sky130_fd_sc_hd__decap_3
XFILLER_34_514 VGND VGND VPWR VPWR sky130_fd_sc_hd__fill_1
XFILLER_74_672 VGND VGND VPWR VPWR sky130_fd_sc_hd__decap_3
XFILLER_34_536 VGND VGND VPWR VPWR sky130_fd_sc_hd__decap_3
XFILLER_34_547 VGND VGND VPWR VPWR sky130_fd_sc_hd__decap_3
XFILLER_61_377 VGND VGND VPWR VPWR sky130_fd_sc_hd__decap_3
XFILLER_14_271 VGND VGND VPWR VPWR sky130_fd_sc_hd__decap_3
XFILLER_42_580 VGND VGND VPWR VPWR sky130_fd_sc_hd__decap_3
XTAP_TAPCELL_ROW_64_1061 VGND VPWR sky130_fd_sc_hd__tapvpwrvgnd_1
XFILLER_9_54 VGND VGND VPWR VPWR sky130_fd_sc_hd__fill_2
X_4660_ _4720_/A _4655_/X _4658_/A VGND VGND VPWR VPWR _4660_/X sky130_fd_sc_hd__a21bo_2
XFILLER_80_91 VGND VGND VPWR VPWR sky130_fd_sc_hd__decap_3
X_3611_ _5057_/A _3611_/B VGND VGND VPWR VPWR _3611_/Y sky130_fd_sc_hd__nor2_2
X_6330_ _6550_/A VGND VGND VPWR VPWR _6330_/Y sky130_fd_sc_hd__inv_2
X_4591_ _4591_/A _4595_/B VGND VGND VPWR VPWR _7285_/D sky130_fd_sc_hd__and2_2
XTAP_TAPCELL_ROW_116_1714 VGND VPWR sky130_fd_sc_hd__tapvpwrvgnd_1
XTAP_TAPCELL_ROW_116_1703 VGND VPWR sky130_fd_sc_hd__tapvpwrvgnd_1
XFILLER_115_324 VGND VGND VPWR VPWR sky130_fd_sc_hd__decap_3
Xhold905 _6950_/Q VGND VGND VPWR VPWR _6950_/D sky130_fd_sc_hd__dlygate4sd3_1
Xhold916 _6869_/Q VGND VGND VPWR VPWR _6869_/D sky130_fd_sc_hd__dlygate4sd3_1
Xhold927 _6770_/Q VGND VGND VPWR VPWR _6770_/D sky130_fd_sc_hd__dlygate4sd3_1
XFILLER_89_709 VGND VGND VPWR VPWR sky130_fd_sc_hd__decap_3
Xhold938 _6855_/Q VGND VGND VPWR VPWR _6855_/D sky130_fd_sc_hd__dlygate4sd3_1
Xhold949 _7116_/Q VGND VGND VPWR VPWR _7116_/D sky130_fd_sc_hd__dlygate4sd3_1
Xmax_cap668 _4275_/Y VGND VGND VPWR VPWR _4987_/A sky130_fd_sc_hd__buf_2
X_6261_ _6463_/A VGND VGND VPWR VPWR _6261_/Y sky130_fd_sc_hd__inv_2
X_3473_ _7312_/Q _4471_/S _4346_/B1 _7344_/Q _4347_/C1 VGND VGND VPWR VPWR _3473_/X
+ sky130_fd_sc_hd__a221o_2
XTAP_TAPCELL_ROW_75_1190 VGND VPWR sky130_fd_sc_hd__tapvpwrvgnd_1
XFILLER_29_319 VGND VGND VPWR VPWR sky130_fd_sc_hd__decap_3
XFILLER_57_617 VGND VGND VPWR VPWR sky130_fd_sc_hd__decap_3
XFILLER_69_466 VGND VGND VPWR VPWR sky130_fd_sc_hd__decap_3
XFILLER_111_585 VGND VGND VPWR VPWR sky130_fd_sc_hd__decap_3
XFILLER_56_127 VGND VGND VPWR VPWR sky130_fd_sc_hd__decap_3
XFILLER_84_414 VGND VGND VPWR VPWR sky130_fd_sc_hd__fill_2
X_5074_ _4852_/A _5073_/A _5073_/Y _4811_/C VGND VGND VPWR VPWR _5075_/C sky130_fd_sc_hd__a2bb2o_2
XFILLER_65_650 VGND VGND VPWR VPWR sky130_fd_sc_hd__decap_3
XFILLER_37_352 VGND VGND VPWR VPWR sky130_fd_sc_hd__decap_3
XFILLER_52_300 VGND VGND VPWR VPWR sky130_fd_sc_hd__fill_1
XFILLER_65_694 VGND VGND VPWR VPWR sky130_fd_sc_hd__decap_3
XFILLER_71_108 VGND VGND VPWR VPWR sky130_fd_sc_hd__decap_3
XFILLER_71_119 VGND VGND VPWR VPWR sky130_fd_sc_hd__decap_3
XFILLER_25_558 VGND VGND VPWR VPWR sky130_fd_sc_hd__fill_2
XFILLER_44_29 VGND VGND VPWR VPWR sky130_fd_sc_hd__fill_2
XFILLER_52_333 VGND VGND VPWR VPWR sky130_fd_sc_hd__decap_3
XFILLER_64_171 VGND VGND VPWR VPWR sky130_fd_sc_hd__decap_3
XFILLER_80_642 VGND VGND VPWR VPWR sky130_fd_sc_hd__fill_2
XFILLER_92_480 VGND VGND VPWR VPWR sky130_fd_sc_hd__decap_3
XFILLER_13_709 VGND VGND VPWR VPWR sky130_fd_sc_hd__decap_3
XFILLER_52_355 VGND VGND VPWR VPWR sky130_fd_sc_hd__decap_3
XFILLER_52_377 VGND VGND VPWR VPWR sky130_fd_sc_hd__decap_3
XFILLER_80_675 VGND VGND VPWR VPWR sky130_fd_sc_hd__decap_3
XFILLER_100_24 VGND VGND VPWR VPWR sky130_fd_sc_hd__decap_3
XFILLER_33_591 VGND VGND VPWR VPWR sky130_fd_sc_hd__decap_3
XFILLER_40_539 VGND VGND VPWR VPWR sky130_fd_sc_hd__decap_3
X_4927_ _5579_/S _4927_/B _4927_/C VGND VGND VPWR VPWR _4927_/X sky130_fd_sc_hd__or3_2
XFILLER_100_68 VGND VGND VPWR VPWR sky130_fd_sc_hd__decap_3
X_4858_ _6999_/Q _4858_/B VGND VGND VPWR VPWR _4870_/A sky130_fd_sc_hd__and2_2
XFILLER_20_274 VGND VGND VPWR VPWR sky130_fd_sc_hd__decap_3
X_3809_ _6836_/Q _3910_/B1 _3911_/B1 _6841_/Q VGND VGND VPWR VPWR _3809_/X sky130_fd_sc_hd__a22o_2
X_4789_ _5057_/A _4412_/B _4413_/A _4852_/A _4788_/Y VGND VGND VPWR VPWR _4789_/X
+ sky130_fd_sc_hd__o221a_2
XFILLER_109_33 VGND VGND VPWR VPWR sky130_fd_sc_hd__decap_3
XFILLER_119_696 VGND VGND VPWR VPWR sky130_fd_sc_hd__decap_3
XFILLER_4_418 VGND VGND VPWR VPWR sky130_fd_sc_hd__fill_2
X_6528_ _6535_/A VGND VGND VPWR VPWR _6528_/Y sky130_fd_sc_hd__inv_2
XFILLER_107_6 VGND VGND VPWR VPWR sky130_fd_sc_hd__decap_3
XFILLER_109_66 VGND VGND VPWR VPWR sky130_fd_sc_hd__decap_3
XFILLER_118_195 VGND VGND VPWR VPWR sky130_fd_sc_hd__fill_1
X_6459_ _6556_/A VGND VGND VPWR VPWR _6459_/Y sky130_fd_sc_hd__inv_2
XFILLER_106_368 VGND VGND VPWR VPWR sky130_fd_sc_hd__decap_3
XFILLER_79_219 VGND VGND VPWR VPWR sky130_fd_sc_hd__decap_3
XFILLER_0_657 VGND VGND VPWR VPWR sky130_fd_sc_hd__fill_1
XFILLER_0_679 VGND VGND VPWR VPWR sky130_fd_sc_hd__decap_3
XFILLER_48_617 VGND VGND VPWR VPWR sky130_fd_sc_hd__decap_3
XFILLER_87_252 VGND VGND VPWR VPWR sky130_fd_sc_hd__decap_3
XFILLER_47_105 VGND VGND VPWR VPWR sky130_fd_sc_hd__decap_3
XFILLER_85_69 VGND VGND VPWR VPWR sky130_fd_sc_hd__decap_3
XFILLER_18_63 VGND VGND VPWR VPWR sky130_fd_sc_hd__decap_3
XFILLER_18_85 VGND VGND VPWR VPWR sky130_fd_sc_hd__decap_3
XFILLER_28_374 VGND VGND VPWR VPWR sky130_fd_sc_hd__decap_3
XFILLER_56_672 VGND VGND VPWR VPWR sky130_fd_sc_hd__decap_3
XFILLER_62_108 VGND VGND VPWR VPWR sky130_fd_sc_hd__decap_3
XTAP_TAPCELL_ROW_46_829 VGND VPWR sky130_fd_sc_hd__tapvpwrvgnd_1
XFILLER_43_311 VGND VGND VPWR VPWR sky130_fd_sc_hd__decap_3
XFILLER_71_620 VGND VGND VPWR VPWR sky130_fd_sc_hd__decap_3
XFILLER_71_653 VGND VGND VPWR VPWR sky130_fd_sc_hd__decap_3
XFILLER_83_491 VGND VGND VPWR VPWR sky130_fd_sc_hd__decap_3
XFILLER_70_130 VGND VGND VPWR VPWR sky130_fd_sc_hd__decap_3
XFILLER_70_141 VGND VGND VPWR VPWR sky130_fd_sc_hd__fill_2
XFILLER_24_580 VGND VGND VPWR VPWR sky130_fd_sc_hd__decap_3
XFILLER_31_528 VGND VGND VPWR VPWR sky130_fd_sc_hd__decap_3
XFILLER_70_174 VGND VGND VPWR VPWR sky130_fd_sc_hd__fill_2
XFILLER_71_697 VGND VGND VPWR VPWR sky130_fd_sc_hd__decap_3
XTAP_TAPCELL_ROW_26_586 VGND VPWR sky130_fd_sc_hd__tapvpwrvgnd_1
XTAP_TAPCELL_ROW_100_1504 VGND VPWR sky130_fd_sc_hd__tapvpwrvgnd_1
XFILLER_8_713 VGND VGND VPWR VPWR sky130_fd_sc_hd__fill_1
XFILLER_109_140 VGND VGND VPWR VPWR sky130_fd_sc_hd__decap_3
XFILLER_109_184 VGND VGND VPWR VPWR sky130_fd_sc_hd__decap_3
XFILLER_112_305 VGND VGND VPWR VPWR sky130_fd_sc_hd__decap_3
XFILLER_98_517 VGND VGND VPWR VPWR sky130_fd_sc_hd__fill_2
XFILLER_98_528 VGND VGND VPWR VPWR sky130_fd_sc_hd__decap_3
XFILLER_98_539 VGND VGND VPWR VPWR sky130_fd_sc_hd__decap_3
XFILLER_112_349 VGND VGND VPWR VPWR sky130_fd_sc_hd__decap_3
XFILLER_3_484 VGND VGND VPWR VPWR sky130_fd_sc_hd__decap_3
XTAP_TAPCELL_ROW_111_1644 VGND VPWR sky130_fd_sc_hd__tapvpwrvgnd_1
XFILLER_39_617 VGND VGND VPWR VPWR sky130_fd_sc_hd__decap_3
XFILLER_66_403 VGND VGND VPWR VPWR sky130_fd_sc_hd__decap_3
XFILLER_78_230 VGND VGND VPWR VPWR sky130_fd_sc_hd__decap_3
XFILLER_94_701 VGND VGND VPWR VPWR sky130_fd_sc_hd__decap_3
XFILLER_38_127 VGND VGND VPWR VPWR sky130_fd_sc_hd__decap_3
XFILLER_19_330 VGND VGND VPWR VPWR sky130_fd_sc_hd__fill_1
XFILLER_47_650 VGND VGND VPWR VPWR sky130_fd_sc_hd__decap_3
XFILLER_54_609 VGND VGND VPWR VPWR sky130_fd_sc_hd__decap_3
XFILLER_81_406 VGND VGND VPWR VPWR sky130_fd_sc_hd__fill_1
XFILLER_93_266 VGND VGND VPWR VPWR sky130_fd_sc_hd__fill_1
XFILLER_19_396 VGND VGND VPWR VPWR sky130_fd_sc_hd__fill_1
XFILLER_34_333 VGND VGND VPWR VPWR sky130_fd_sc_hd__decap_3
XFILLER_46_171 VGND VGND VPWR VPWR sky130_fd_sc_hd__decap_3
XFILLER_47_694 VGND VGND VPWR VPWR sky130_fd_sc_hd__decap_3
XFILLER_62_620 VGND VGND VPWR VPWR sky130_fd_sc_hd__decap_3
XFILLER_93_299 VGND VGND VPWR VPWR sky130_fd_sc_hd__decap_3
XFILLER_22_506 VGND VGND VPWR VPWR sky130_fd_sc_hd__fill_2
XFILLER_34_344 VGND VGND VPWR VPWR sky130_fd_sc_hd__decap_3
XFILLER_61_152 VGND VGND VPWR VPWR sky130_fd_sc_hd__decap_3
XFILLER_62_675 VGND VGND VPWR VPWR sky130_fd_sc_hd__decap_3
XFILLER_61_185 VGND VGND VPWR VPWR sky130_fd_sc_hd__decap_3
X_4712_ _7007_/Q _4738_/A VGND VGND VPWR VPWR _4731_/B sky130_fd_sc_hd__nand2_2
X_4643_ _4888_/A _4125_/X _4126_/A VGND VGND VPWR VPWR _4643_/Y sky130_fd_sc_hd__a21oi_2
XFILLER_116_622 VGND VGND VPWR VPWR sky130_fd_sc_hd__decap_3
X_7362_ _7362_/CLK _7362_/D _6642_/Y VGND VGND VPWR VPWR _7362_/Q sky130_fd_sc_hd__dfrtp_2
Xhold702 _6799_/Q VGND VGND VPWR VPWR _6799_/D sky130_fd_sc_hd__dlygate4sd3_1
XFILLER_116_666 VGND VGND VPWR VPWR sky130_fd_sc_hd__decap_3
X_7293_ _7322_/CLK _7293_/D _6573_/Y VGND VGND VPWR VPWR _7293_/Q sky130_fd_sc_hd__dfrtp_2
Xhold713 _6924_/Q VGND VGND VPWR VPWR _6924_/D sky130_fd_sc_hd__dlygate4sd3_1
Xhold724 _6719_/Q VGND VGND VPWR VPWR _6719_/D sky130_fd_sc_hd__dlygate4sd3_1
Xhold735 _6825_/Q VGND VGND VPWR VPWR _6825_/D sky130_fd_sc_hd__dlygate4sd3_1
Xhold746 _6973_/Q VGND VGND VPWR VPWR _6973_/D sky130_fd_sc_hd__dlygate4sd3_1
X_6313_ _6625_/A VGND VGND VPWR VPWR _6313_/Y sky130_fd_sc_hd__inv_2
X_3525_ _3525_/A _3525_/B VGND VGND VPWR VPWR _5072_/A sky130_fd_sc_hd__and2_2
XFILLER_116_699 VGND VGND VPWR VPWR sky130_fd_sc_hd__fill_1
Xhold757 _6865_/Q VGND VGND VPWR VPWR _6865_/D sky130_fd_sc_hd__dlygate4sd3_1
Xhold768 _6970_/Q VGND VGND VPWR VPWR _6970_/D sky130_fd_sc_hd__dlygate4sd3_1
Xhold779 _6871_/Q VGND VGND VPWR VPWR _6871_/D sky130_fd_sc_hd__dlygate4sd3_1
XFILLER_103_327 VGND VGND VPWR VPWR sky130_fd_sc_hd__decap_3
X_3456_ _7011_/Q _4601_/S _3448_/X _3455_/X VGND VGND VPWR VPWR _3456_/X sky130_fd_sc_hd__a211o_2
XFILLER_85_712 VGND VGND VPWR VPWR sky130_fd_sc_hd__fill_2
XFILLER_97_550 VGND VGND VPWR VPWR sky130_fd_sc_hd__decap_3
XFILLER_97_561 VGND VGND VPWR VPWR sky130_fd_sc_hd__decap_3
X_3387_ _3385_/Y _3386_/Y _3566_/A2 _3399_/B VGND VGND VPWR VPWR _3429_/B sky130_fd_sc_hd__a211o_2
XFILLER_111_371 VGND VGND VPWR VPWR sky130_fd_sc_hd__fill_1
XFILLER_29_127 VGND VGND VPWR VPWR sky130_fd_sc_hd__fill_1
XFILLER_69_263 VGND VGND VPWR VPWR sky130_fd_sc_hd__decap_3
XFILLER_69_296 VGND VGND VPWR VPWR sky130_fd_sc_hd__decap_3
XFILLER_84_200 VGND VGND VPWR VPWR sky130_fd_sc_hd__decap_3
X_5126_ _5126_/A0 _5125_/Y _5136_/S VGND VGND VPWR VPWR _7253_/D sky130_fd_sc_hd__mux2_2
XFILLER_55_17 VGND VGND VPWR VPWR sky130_fd_sc_hd__fill_1
XFILLER_57_447 VGND VGND VPWR VPWR sky130_fd_sc_hd__fill_1
XFILLER_84_233 VGND VGND VPWR VPWR sky130_fd_sc_hd__decap_3
X_5057_ _5057_/A _5057_/B VGND VGND VPWR VPWR _5057_/Y sky130_fd_sc_hd__nor2_2
XFILLER_38_672 VGND VGND VPWR VPWR sky130_fd_sc_hd__decap_3
XFILLER_72_406 VGND VGND VPWR VPWR sky130_fd_sc_hd__fill_2
XFILLER_72_417 VGND VGND VPWR VPWR sky130_fd_sc_hd__decap_3
XFILLER_84_266 VGND VGND VPWR VPWR sky130_fd_sc_hd__decap_3
XFILLER_111_12 VGND VGND VPWR VPWR sky130_fd_sc_hd__decap_3
XFILLER_25_333 VGND VGND VPWR VPWR sky130_fd_sc_hd__decap_3
XFILLER_37_182 VGND VGND VPWR VPWR sky130_fd_sc_hd__decap_3
XFILLER_53_620 VGND VGND VPWR VPWR sky130_fd_sc_hd__decap_3
XFILLER_65_491 VGND VGND VPWR VPWR sky130_fd_sc_hd__decap_3
XFILLER_111_45 VGND VGND VPWR VPWR sky130_fd_sc_hd__decap_3
XFILLER_25_366 VGND VGND VPWR VPWR sky130_fd_sc_hd__decap_3
XFILLER_53_653 VGND VGND VPWR VPWR sky130_fd_sc_hd__decap_3
XFILLER_111_78 VGND VGND VPWR VPWR sky130_fd_sc_hd__decap_3
XFILLER_53_697 VGND VGND VPWR VPWR sky130_fd_sc_hd__decap_3
XFILLER_80_472 VGND VGND VPWR VPWR sky130_fd_sc_hd__decap_3
XTAP_TAPCELL_ROW_23_545 VGND VPWR sky130_fd_sc_hd__tapvpwrvgnd_1
XFILLER_21_561 VGND VGND VPWR VPWR sky130_fd_sc_hd__decap_3
XTAP_TAPCELL_ROW_51_898 VGND VPWR sky130_fd_sc_hd__tapvpwrvgnd_1
XFILLER_21_594 VGND VGND VPWR VPWR sky130_fd_sc_hd__decap_3
XFILLER_105_3 VGND VGND VPWR VPWR sky130_fd_sc_hd__decap_3
XFILLER_106_110 VGND VGND VPWR VPWR sky130_fd_sc_hd__decap_3
XFILLER_107_644 VGND VGND VPWR VPWR sky130_fd_sc_hd__decap_3
XFILLER_20_42 VGND VGND VPWR VPWR sky130_fd_sc_hd__decap_3
XFILLER_107_688 VGND VGND VPWR VPWR sky130_fd_sc_hd__decap_3
XFILLER_4_259 VGND VGND VPWR VPWR sky130_fd_sc_hd__decap_3
XFILLER_0_432 VGND VGND VPWR VPWR sky130_fd_sc_hd__decap_3
XFILLER_76_701 VGND VGND VPWR VPWR sky130_fd_sc_hd__decap_3
XFILLER_88_550 VGND VGND VPWR VPWR sky130_fd_sc_hd__decap_3
XFILLER_0_498 VGND VGND VPWR VPWR sky130_fd_sc_hd__decap_3
XFILLER_102_360 VGND VGND VPWR VPWR sky130_fd_sc_hd__decap_3
XFILLER_75_211 VGND VGND VPWR VPWR sky130_fd_sc_hd__fill_1
XFILLER_88_572 VGND VGND VPWR VPWR sky130_fd_sc_hd__decap_3
XFILLER_75_255 VGND VGND VPWR VPWR sky130_fd_sc_hd__decap_3
XFILLER_29_650 VGND VGND VPWR VPWR sky130_fd_sc_hd__decap_3
XFILLER_63_428 VGND VGND VPWR VPWR sky130_fd_sc_hd__decap_3
XFILLER_75_288 VGND VGND VPWR VPWR sky130_fd_sc_hd__decap_3
XTAP_TAPCELL_ROW_59_998 VGND VPWR sky130_fd_sc_hd__tapvpwrvgnd_1
XFILLER_28_171 VGND VGND VPWR VPWR sky130_fd_sc_hd__decap_3
XFILLER_29_694 VGND VGND VPWR VPWR sky130_fd_sc_hd__decap_3
XFILLER_44_631 VGND VGND VPWR VPWR sky130_fd_sc_hd__decap_3
XFILLER_56_491 VGND VGND VPWR VPWR sky130_fd_sc_hd__decap_3
Xplace428 _5151_/A VGND VGND VPWR VPWR _3864_/S sky130_fd_sc_hd__buf_2
Xplace417 _4352_/B1 VGND VGND VPWR VPWR _4267_/B1 sky130_fd_sc_hd__buf_2
Xplace406 _4351_/A2 VGND VGND VPWR VPWR _4417_/B1 sky130_fd_sc_hd__buf_2
XTAP_TAPCELL_ROW_3_292 VGND VPWR sky130_fd_sc_hd__tapvpwrvgnd_1
XFILLER_43_141 VGND VGND VPWR VPWR sky130_fd_sc_hd__fill_1
XFILLER_44_675 VGND VGND VPWR VPWR sky130_fd_sc_hd__decap_3
XFILLER_71_461 VGND VGND VPWR VPWR sky130_fd_sc_hd__decap_3
Xplace439 _5211_/B VGND VGND VPWR VPWR _5198_/B sky130_fd_sc_hd__buf_2
XFILLER_43_163 VGND VGND VPWR VPWR sky130_fd_sc_hd__decap_3
XFILLER_31_369 VGND VGND VPWR VPWR sky130_fd_sc_hd__decap_3
XFILLER_43_196 VGND VGND VPWR VPWR sky130_fd_sc_hd__decap_3
XTAP_TAPCELL_ROW_61_1020 VGND VPWR sky130_fd_sc_hd__tapvpwrvgnd_1
XFILLER_12_572 VGND VGND VPWR VPWR sky130_fd_sc_hd__decap_3
XFILLER_8_554 VGND VGND VPWR VPWR sky130_fd_sc_hd__decap_3
XFILLER_117_419 VGND VGND VPWR VPWR sky130_fd_sc_hd__decap_3
XFILLER_8_587 VGND VGND VPWR VPWR sky130_fd_sc_hd__fill_1
XFILLER_8_598 VGND VGND VPWR VPWR sky130_fd_sc_hd__decap_3
XANTENNA_4 _4380_/B VGND VGND VPWR VPWR sky130_fd_sc_hd__diode_2
XFILLER_113_603 VGND VGND VPWR VPWR sky130_fd_sc_hd__decap_3
X_3310_ _5118_/C _3519_/B _3383_/B _3340_/A VGND VGND VPWR VPWR _3310_/Y sky130_fd_sc_hd__a31oi_2
XFILLER_113_647 VGND VGND VPWR VPWR sky130_fd_sc_hd__decap_3
XFILLER_3_270 VGND VGND VPWR VPWR sky130_fd_sc_hd__decap_3
XFILLER_3_281 VGND VGND VPWR VPWR sky130_fd_sc_hd__decap_3
X_4290_ _4283_/X _4288_/X _5647_/B _4649_/A VGND VGND VPWR VPWR _4612_/B sky130_fd_sc_hd__a2bb2o_4
XFILLER_112_157 VGND VGND VPWR VPWR sky130_fd_sc_hd__decap_3
XFILLER_79_561 VGND VGND VPWR VPWR sky130_fd_sc_hd__decap_3
XFILLER_86_509 VGND VGND VPWR VPWR sky130_fd_sc_hd__decap_3
XTAP_TAPCELL_ROW_72_1160 VGND VPWR sky130_fd_sc_hd__tapvpwrvgnd_1
XFILLER_20_3 VGND VGND VPWR VPWR sky130_fd_sc_hd__fill_1
XFILLER_66_200 VGND VGND VPWR VPWR sky130_fd_sc_hd__decap_3
XFILLER_67_712 VGND VGND VPWR VPWR sky130_fd_sc_hd__fill_2
XFILLER_27_609 VGND VGND VPWR VPWR sky130_fd_sc_hd__decap_3
XFILLER_39_458 VGND VGND VPWR VPWR sky130_fd_sc_hd__fill_1
XFILLER_66_233 VGND VGND VPWR VPWR sky130_fd_sc_hd__decap_3
XFILLER_94_531 VGND VGND VPWR VPWR sky130_fd_sc_hd__fill_1
XFILLER_54_417 VGND VGND VPWR VPWR sky130_fd_sc_hd__decap_3
XFILLER_66_266 VGND VGND VPWR VPWR sky130_fd_sc_hd__decap_3
XFILLER_66_288 VGND VGND VPWR VPWR sky130_fd_sc_hd__decap_3
XFILLER_82_704 VGND VGND VPWR VPWR sky130_fd_sc_hd__decap_3
XFILLER_35_620 VGND VGND VPWR VPWR sky130_fd_sc_hd__decap_3
XFILLER_54_439 VGND VGND VPWR VPWR sky130_fd_sc_hd__decap_3
XFILLER_81_225 VGND VGND VPWR VPWR sky130_fd_sc_hd__fill_1
X_6931_ _6943_/CLK _6931_/D VGND VGND VPWR VPWR _6931_/Q sky130_fd_sc_hd__dfxtp_2
XFILLER_34_141 VGND VGND VPWR VPWR sky130_fd_sc_hd__decap_3
XFILLER_35_653 VGND VGND VPWR VPWR sky130_fd_sc_hd__decap_3
X_6862_ _6968_/CLK _6862_/D VGND VGND VPWR VPWR _6862_/Q sky130_fd_sc_hd__dfxtp_2
XFILLER_22_303 VGND VGND VPWR VPWR sky130_fd_sc_hd__decap_3
XFILLER_35_697 VGND VGND VPWR VPWR sky130_fd_sc_hd__decap_3
XFILLER_50_623 VGND VGND VPWR VPWR sky130_fd_sc_hd__decap_3
XFILLER_62_483 VGND VGND VPWR VPWR sky130_fd_sc_hd__decap_3
XFILLER_22_358 VGND VGND VPWR VPWR sky130_fd_sc_hd__decap_3
XFILLER_50_645 VGND VGND VPWR VPWR sky130_fd_sc_hd__decap_3
X_6793_ _7189_/CLK _6793_/D VGND VGND VPWR VPWR _6793_/Q sky130_fd_sc_hd__dfxtp_2
XFILLER_50_678 VGND VGND VPWR VPWR sky130_fd_sc_hd__decap_3
XTAP_TAPCELL_ROW_20_504 VGND VPWR sky130_fd_sc_hd__tapvpwrvgnd_1
XFILLER_30_391 VGND VGND VPWR VPWR sky130_fd_sc_hd__decap_3
XFILLER_108_419 VGND VGND VPWR VPWR sky130_fd_sc_hd__fill_1
X_4626_ _4256_/C _4626_/B _4626_/C VGND VGND VPWR VPWR _4626_/X sky130_fd_sc_hd__and3b_2
XFILLER_116_441 VGND VGND VPWR VPWR sky130_fd_sc_hd__decap_3
X_7345_ _7345_/CLK _7345_/D _6625_/Y VGND VGND VPWR VPWR _7345_/Q sky130_fd_sc_hd__dfrtp_2
XFILLER_116_474 VGND VGND VPWR VPWR sky130_fd_sc_hd__fill_2
XFILLER_103_113 VGND VGND VPWR VPWR sky130_fd_sc_hd__decap_3
XFILLER_104_625 VGND VGND VPWR VPWR sky130_fd_sc_hd__decap_3
XFILLER_89_325 VGND VGND VPWR VPWR sky130_fd_sc_hd__decap_3
X_7276_ _7372_/CLK _7276_/D _6556_/Y VGND VGND VPWR VPWR _7276_/Q sky130_fd_sc_hd__dfrtp_2
X_4488_ _4488_/A0 _7303_/Q _4488_/S VGND VGND VPWR VPWR _4488_/X sky130_fd_sc_hd__mux2_2
X_3508_ _3508_/A _3508_/B VGND VGND VPWR VPWR _3508_/Y sky130_fd_sc_hd__nor2_2
XFILLER_103_146 VGND VGND VPWR VPWR sky130_fd_sc_hd__decap_3
XFILLER_104_669 VGND VGND VPWR VPWR sky130_fd_sc_hd__decap_3
XFILLER_106_23 VGND VGND VPWR VPWR sky130_fd_sc_hd__decap_3
XFILLER_58_701 VGND VGND VPWR VPWR sky130_fd_sc_hd__decap_3
X_3439_ _7282_/Q _4532_/S _4339_/B1 _7154_/Q _3438_/X VGND VGND VPWR VPWR _3439_/X
+ sky130_fd_sc_hd__a221o_2
XFILLER_57_200 VGND VGND VPWR VPWR sky130_fd_sc_hd__decap_3
XFILLER_66_38 VGND VGND VPWR VPWR sky130_fd_sc_hd__fill_1
Xhold1210 _7309_/Q VGND VGND VPWR VPWR _4542_/A sky130_fd_sc_hd__dlygate4sd3_1
Xhold1221 _7158_/Q VGND VGND VPWR VPWR _5346_/A0 sky130_fd_sc_hd__dlygate4sd3_1
Xhold1232 _7164_/Q VGND VGND VPWR VPWR _5333_/A0 sky130_fd_sc_hd__dlygate4sd3_1
Xhold1243 _7170_/Q VGND VGND VPWR VPWR _5321_/A0 sky130_fd_sc_hd__dlygate4sd3_1
XFILLER_72_203 VGND VGND VPWR VPWR sky130_fd_sc_hd__decap_3
Xhold1254 _7342_/Q VGND VGND VPWR VPWR _4474_/A0 sky130_fd_sc_hd__dlygate4sd3_1
Xhold1265 _7285_/Q VGND VGND VPWR VPWR _4591_/A sky130_fd_sc_hd__dlygate4sd3_1
Xhold1276 _7144_/Q VGND VGND VPWR VPWR _5377_/A0 sky130_fd_sc_hd__dlygate4sd3_1
XTAP_TAPCELL_ROW_28_604 VGND VPWR sky130_fd_sc_hd__tapvpwrvgnd_1
XFILLER_26_631 VGND VGND VPWR VPWR sky130_fd_sc_hd__decap_3
XFILLER_38_480 VGND VGND VPWR VPWR sky130_fd_sc_hd__fill_1
XFILLER_45_439 VGND VGND VPWR VPWR sky130_fd_sc_hd__fill_1
XFILLER_72_225 VGND VGND VPWR VPWR sky130_fd_sc_hd__decap_3
Xhold1287 _7142_/Q VGND VGND VPWR VPWR _5381_/A0 sky130_fd_sc_hd__dlygate4sd3_1
Xhold1298 _7145_/Q VGND VGND VPWR VPWR _5375_/A0 sky130_fd_sc_hd__dlygate4sd3_1
XTAP_TAPCELL_ROW_86_1329 VGND VPWR sky130_fd_sc_hd__tapvpwrvgnd_1
XTAP_TAPCELL_ROW_56_957 VGND VPWR sky130_fd_sc_hd__tapvpwrvgnd_1
XFILLER_25_141 VGND VGND VPWR VPWR sky130_fd_sc_hd__fill_1
XFILLER_26_675 VGND VGND VPWR VPWR sky130_fd_sc_hd__decap_3
XFILLER_72_247 VGND VGND VPWR VPWR sky130_fd_sc_hd__fill_2
XFILLER_82_26 VGND VGND VPWR VPWR sky130_fd_sc_hd__fill_2
XTAP_TAPCELL_ROW_0_262 VGND VPWR sky130_fd_sc_hd__tapvpwrvgnd_1
XTAP_TAPCELL_ROW_0_251 VGND VPWR sky130_fd_sc_hd__tapvpwrvgnd_1
XTAP_TAPCELL_ROW_0_240 VGND VPWR sky130_fd_sc_hd__tapvpwrvgnd_1
XFILLER_13_325 VGND VGND VPWR VPWR sky130_fd_sc_hd__decap_3
XFILLER_41_612 VGND VGND VPWR VPWR sky130_fd_sc_hd__decap_3
XFILLER_41_623 VGND VGND VPWR VPWR sky130_fd_sc_hd__decap_3
XFILLER_53_472 VGND VGND VPWR VPWR sky130_fd_sc_hd__decap_3
XFILLER_13_358 VGND VGND VPWR VPWR sky130_fd_sc_hd__decap_3
XFILLER_15_53 VGND VGND VPWR VPWR sky130_fd_sc_hd__decap_3
XFILLER_41_656 VGND VGND VPWR VPWR sky130_fd_sc_hd__decap_3
XFILLER_9_329 VGND VGND VPWR VPWR sky130_fd_sc_hd__decap_3
XTAP_TAPCELL_ROW_97_1469 VGND VPWR sky130_fd_sc_hd__tapvpwrvgnd_1
XFILLER_107_452 VGND VGND VPWR VPWR sky130_fd_sc_hd__decap_3
XFILLER_5_557 VGND VGND VPWR VPWR sky130_fd_sc_hd__decap_3
XFILLER_5_579 VGND VGND VPWR VPWR sky130_fd_sc_hd__decap_3
XFILLER_107_485 VGND VGND VPWR VPWR sky130_fd_sc_hd__decap_3
XTAP_TAPCELL_ROW_8_362 VGND VPWR sky130_fd_sc_hd__tapvpwrvgnd_1
XFILLER_0_240 VGND VGND VPWR VPWR sky130_fd_sc_hd__decap_3
XFILLER_110_628 VGND VGND VPWR VPWR sky130_fd_sc_hd__decap_3
XFILLER_49_712 VGND VGND VPWR VPWR sky130_fd_sc_hd__fill_2
XFILLER_95_317 VGND VGND VPWR VPWR sky130_fd_sc_hd__decap_3
XFILLER_0_284 VGND VGND VPWR VPWR sky130_fd_sc_hd__decap_3
XFILLER_103_691 VGND VGND VPWR VPWR sky130_fd_sc_hd__decap_3
XFILLER_48_222 VGND VGND VPWR VPWR sky130_fd_sc_hd__decap_3
XFILLER_88_380 VGND VGND VPWR VPWR sky130_fd_sc_hd__decap_3
XFILLER_48_277 VGND VGND VPWR VPWR sky130_fd_sc_hd__decap_3
XFILLER_64_704 VGND VGND VPWR VPWR sky130_fd_sc_hd__decap_3
XFILLER_91_501 VGND VGND VPWR VPWR sky130_fd_sc_hd__decap_3
XFILLER_17_620 VGND VGND VPWR VPWR sky130_fd_sc_hd__decap_3
XFILLER_63_225 VGND VGND VPWR VPWR sky130_fd_sc_hd__fill_1
XFILLER_91_523 VGND VGND VPWR VPWR sky130_fd_sc_hd__decap_3
XFILLER_17_653 VGND VGND VPWR VPWR sky130_fd_sc_hd__decap_3
XFILLER_91_556 VGND VGND VPWR VPWR sky130_fd_sc_hd__decap_3
XFILLER_91_567 VGND VGND VPWR VPWR sky130_fd_sc_hd__decap_3
XFILLER_16_152 VGND VGND VPWR VPWR sky130_fd_sc_hd__decap_3
XFILLER_16_174 VGND VGND VPWR VPWR sky130_fd_sc_hd__fill_2
XFILLER_17_697 VGND VGND VPWR VPWR sky130_fd_sc_hd__decap_3
XFILLER_32_601 VGND VGND VPWR VPWR sky130_fd_sc_hd__decap_3
XFILLER_91_589 VGND VGND VPWR VPWR sky130_fd_sc_hd__decap_3
XTAP_TAPCELL_ROW_106_1587 VGND VPWR sky130_fd_sc_hd__tapvpwrvgnd_1
XFILLER_31_122 VGND VGND VPWR VPWR sky130_fd_sc_hd__decap_3
XFILLER_32_634 VGND VGND VPWR VPWR sky130_fd_sc_hd__decap_3
XFILLER_32_645 VGND VGND VPWR VPWR sky130_fd_sc_hd__decap_3
XFILLER_31_155 VGND VGND VPWR VPWR sky130_fd_sc_hd__fill_1
XFILLER_32_678 VGND VGND VPWR VPWR sky130_fd_sc_hd__decap_3
X_3790_ _3746_/X _3777_/X _3779_/X _3629_/A _3789_/X VGND VGND VPWR VPWR _3790_/X
+ sky130_fd_sc_hd__a221o_2
XFILLER_68_3 VGND VGND VPWR VPWR sky130_fd_sc_hd__decap_3
X_4411_ _4411_/A _4411_/B VGND VGND VPWR VPWR _4412_/B sky130_fd_sc_hd__and2_2
Xoutput626 _5643_/X VGND VGND VPWR VPWR instruction_out[5] sky130_fd_sc_hd__clkdlybuf4s25_1
Xoutput615 _3449_/A VGND VGND VPWR VPWR instruction_out[22] sky130_fd_sc_hd__clkdlybuf4s25_1
Xoutput604 _3378_/A VGND VGND VPWR VPWR instruction_out[10] sky130_fd_sc_hd__clkdlybuf4s25_1
XFILLER_98_111 VGND VGND VPWR VPWR sky130_fd_sc_hd__decap_3
X_7130_ _7357_/CLK _7130_/D _6410_/Y VGND VGND VPWR VPWR _7130_/Q sky130_fd_sc_hd__dfrtp_2
Xoutput659 _5670_/A VGND VGND VPWR VPWR pc_out[6] sky130_fd_sc_hd__clkdlybuf4s25_1
Xoutput648 _7002_/Q VGND VGND VPWR VPWR pc_out[25] sky130_fd_sc_hd__clkdlybuf4s25_1
Xoutput637 _6992_/Q VGND VGND VPWR VPWR pc_out[15] sky130_fd_sc_hd__clkdlybuf4s25_1
X_4342_ _7063_/Q _4305_/B _4460_/A VGND VGND VPWR VPWR _4365_/B sky130_fd_sc_hd__o21a_2
XFILLER_99_623 VGND VGND VPWR VPWR sky130_fd_sc_hd__decap_3
X_7061_ _7349_/CLK _7061_/D _6341_/Y VGND VGND VPWR VPWR _7061_/Q sky130_fd_sc_hd__dfrtp_2
X_4273_ _4376_/A _4376_/B _4376_/C _4273_/D VGND VGND VPWR VPWR _4275_/A sky130_fd_sc_hd__nor4_2
XFILLER_99_656 VGND VGND VPWR VPWR sky130_fd_sc_hd__decap_3
XFILLER_101_617 VGND VGND VPWR VPWR sky130_fd_sc_hd__decap_3
XFILLER_86_306 VGND VGND VPWR VPWR sky130_fd_sc_hd__fill_2
.ends
