* NGSPICE file created from single_cycle_cpu.ext - technology: sky130A

* Black-box entry subcircuit for sky130_fd_sc_hd__decap_3 abstract view
.subckt sky130_fd_sc_hd__decap_3 VGND VNB VPB VPWR
.ends

* Black-box entry subcircuit for sky130_fd_sc_hd__fill_1 abstract view
.subckt sky130_fd_sc_hd__fill_1 VGND VNB VPB VPWR
.ends

* Black-box entry subcircuit for sky130_fd_sc_hd__dfxtp_2 abstract view
.subckt sky130_fd_sc_hd__dfxtp_2 CLK D VGND VNB VPB VPWR Q
.ends

* Black-box entry subcircuit for sky130_fd_sc_hd__tapvpwrvgnd_1 abstract view
.subckt sky130_fd_sc_hd__tapvpwrvgnd_1 VGND VPWR
.ends

* Black-box entry subcircuit for sky130_fd_sc_hd__fill_2 abstract view
.subckt sky130_fd_sc_hd__fill_2 VGND VNB VPB VPWR
.ends

* Black-box entry subcircuit for sky130_fd_sc_hd__mux2_2 abstract view
.subckt sky130_fd_sc_hd__mux2_2 A0 A1 S VGND VNB VPB VPWR X
.ends

* Black-box entry subcircuit for sky130_fd_sc_hd__nor4_2 abstract view
.subckt sky130_fd_sc_hd__nor4_2 A B C D VGND VNB VPB VPWR Y
.ends

* Black-box entry subcircuit for sky130_fd_sc_hd__or2_2 abstract view
.subckt sky130_fd_sc_hd__or2_2 A B VGND VNB VPB VPWR X
.ends

* Black-box entry subcircuit for sky130_fd_sc_hd__dfrtp_2 abstract view
.subckt sky130_fd_sc_hd__dfrtp_2 CLK D RESET_B VGND VNB VPB VPWR Q
.ends

* Black-box entry subcircuit for sky130_fd_sc_hd__dlygate4sd3_1 abstract view
.subckt sky130_fd_sc_hd__dlygate4sd3_1 A VGND VNB VPB VPWR X
.ends

* Black-box entry subcircuit for sky130_fd_sc_hd__nor3_2 abstract view
.subckt sky130_fd_sc_hd__nor3_2 A B C VGND VNB VPB VPWR Y
.ends

* Black-box entry subcircuit for sky130_fd_sc_hd__a221o_2 abstract view
.subckt sky130_fd_sc_hd__a221o_2 A1 A2 B1 B2 C1 VGND VNB VPB VPWR X
.ends

* Black-box entry subcircuit for sky130_fd_sc_hd__inv_2 abstract view
.subckt sky130_fd_sc_hd__inv_2 A VGND VNB VPB VPWR Y
.ends

* Black-box entry subcircuit for sky130_fd_sc_hd__a22o_2 abstract view
.subckt sky130_fd_sc_hd__a22o_2 A1 A2 B1 B2 VGND VNB VPB VPWR X
.ends

* Black-box entry subcircuit for sky130_fd_sc_hd__clkdlybuf4s25_1 abstract view
.subckt sky130_fd_sc_hd__clkdlybuf4s25_1 A VGND VNB VPB VPWR X
.ends

* Black-box entry subcircuit for sky130_fd_sc_hd__a211o_2 abstract view
.subckt sky130_fd_sc_hd__a211o_2 A1 A2 B1 C1 VGND VNB VPB VPWR X
.ends

* Black-box entry subcircuit for sky130_fd_sc_hd__and3_4 abstract view
.subckt sky130_fd_sc_hd__and3_4 A B C VGND VNB VPB VPWR X
.ends

* Black-box entry subcircuit for sky130_fd_sc_hd__a31o_2 abstract view
.subckt sky130_fd_sc_hd__a31o_2 A1 A2 A3 B1 VGND VNB VPB VPWR X
.ends

* Black-box entry subcircuit for sky130_fd_sc_hd__or4_4 abstract view
.subckt sky130_fd_sc_hd__or4_4 A B C D VGND VNB VPB VPWR X
.ends

* Black-box entry subcircuit for sky130_fd_sc_hd__nor2_2 abstract view
.subckt sky130_fd_sc_hd__nor2_2 A B VGND VNB VPB VPWR Y
.ends

* Black-box entry subcircuit for sky130_fd_sc_hd__o31a_2 abstract view
.subckt sky130_fd_sc_hd__o31a_2 A1 A2 A3 B1 VGND VNB VPB VPWR X
.ends

* Black-box entry subcircuit for sky130_fd_sc_hd__conb_1 abstract view
.subckt sky130_fd_sc_hd__conb_1 VGND VNB VPB VPWR HI LO
.ends

* Black-box entry subcircuit for sky130_fd_sc_hd__or3b_4 abstract view
.subckt sky130_fd_sc_hd__or3b_4 A B C_N VGND VNB VPB VPWR X
.ends

* Black-box entry subcircuit for sky130_fd_sc_hd__and2_2 abstract view
.subckt sky130_fd_sc_hd__and2_2 A B VGND VNB VPB VPWR X
.ends

* Black-box entry subcircuit for sky130_fd_sc_hd__xnor2_2 abstract view
.subckt sky130_fd_sc_hd__xnor2_2 A B VGND VNB VPB VPWR Y
.ends

* Black-box entry subcircuit for sky130_fd_sc_hd__o21ai_2 abstract view
.subckt sky130_fd_sc_hd__o21ai_2 A1 A2 B1 VGND VNB VPB VPWR Y
.ends

* Black-box entry subcircuit for sky130_fd_sc_hd__nand2_2 abstract view
.subckt sky130_fd_sc_hd__nand2_2 A B VGND VNB VPB VPWR Y
.ends

* Black-box entry subcircuit for sky130_fd_sc_hd__and3_2 abstract view
.subckt sky130_fd_sc_hd__and3_2 A B C VGND VNB VPB VPWR X
.ends

* Black-box entry subcircuit for sky130_fd_sc_hd__and2b_2 abstract view
.subckt sky130_fd_sc_hd__and2b_2 A_N B VGND VNB VPB VPWR X
.ends

* Black-box entry subcircuit for sky130_fd_sc_hd__a21o_2 abstract view
.subckt sky130_fd_sc_hd__a21o_2 A1 A2 B1 VGND VNB VPB VPWR X
.ends

* Black-box entry subcircuit for sky130_fd_sc_hd__or3_2 abstract view
.subckt sky130_fd_sc_hd__or3_2 A B C VGND VNB VPB VPWR X
.ends

* Black-box entry subcircuit for sky130_fd_sc_hd__buf_2 abstract view
.subckt sky130_fd_sc_hd__buf_2 A VGND VNB VPB VPWR X
.ends

* Black-box entry subcircuit for sky130_fd_sc_hd__diode_2 abstract view
.subckt sky130_fd_sc_hd__diode_2 DIODE VGND VNB VPB VPWR
.ends

* Black-box entry subcircuit for sky130_fd_sc_hd__a31oi_4 abstract view
.subckt sky130_fd_sc_hd__a31oi_4 A1 A2 A3 B1 VGND VNB VPB VPWR Y
.ends

* Black-box entry subcircuit for sky130_fd_sc_hd__o21a_2 abstract view
.subckt sky130_fd_sc_hd__o21a_2 A1 A2 B1 VGND VNB VPB VPWR X
.ends

* Black-box entry subcircuit for sky130_fd_sc_hd__o32a_2 abstract view
.subckt sky130_fd_sc_hd__o32a_2 A1 A2 A3 B1 B2 VGND VNB VPB VPWR X
.ends

* Black-box entry subcircuit for sky130_fd_sc_hd__or3b_2 abstract view
.subckt sky130_fd_sc_hd__or3b_2 A B C_N VGND VNB VPB VPWR X
.ends

* Black-box entry subcircuit for sky130_fd_sc_hd__clkbuf_16 abstract view
.subckt sky130_fd_sc_hd__clkbuf_16 A VGND VNB VPB VPWR X
.ends

* Black-box entry subcircuit for sky130_fd_sc_hd__o211ai_2 abstract view
.subckt sky130_fd_sc_hd__o211ai_2 A1 A2 B1 C1 VGND VNB VPB VPWR Y
.ends

* Black-box entry subcircuit for sky130_fd_sc_hd__o22a_2 abstract view
.subckt sky130_fd_sc_hd__o22a_2 A1 A2 B1 B2 VGND VNB VPB VPWR X
.ends

* Black-box entry subcircuit for sky130_fd_sc_hd__o221a_2 abstract view
.subckt sky130_fd_sc_hd__o221a_2 A1 A2 B1 B2 C1 VGND VNB VPB VPWR X
.ends

* Black-box entry subcircuit for sky130_fd_sc_hd__o311a_4 abstract view
.subckt sky130_fd_sc_hd__o311a_4 A1 A2 A3 B1 C1 VGND VNB VPB VPWR X
.ends

* Black-box entry subcircuit for sky130_fd_sc_hd__a211oi_4 abstract view
.subckt sky130_fd_sc_hd__a211oi_4 A1 A2 B1 C1 VGND VNB VPB VPWR Y
.ends

* Black-box entry subcircuit for sky130_fd_sc_hd__xor2_2 abstract view
.subckt sky130_fd_sc_hd__xor2_2 A B VGND VNB VPB VPWR X
.ends

* Black-box entry subcircuit for sky130_fd_sc_hd__or4b_2 abstract view
.subckt sky130_fd_sc_hd__or4b_2 A B C D_N VGND VNB VPB VPWR X
.ends

* Black-box entry subcircuit for sky130_fd_sc_hd__o2bb2a_2 abstract view
.subckt sky130_fd_sc_hd__o2bb2a_2 A1_N A2_N B1 B2 VGND VNB VPB VPWR X
.ends

* Black-box entry subcircuit for sky130_fd_sc_hd__nand3_2 abstract view
.subckt sky130_fd_sc_hd__nand3_2 A B C VGND VNB VPB VPWR Y
.ends

* Black-box entry subcircuit for sky130_fd_sc_hd__o31ai_4 abstract view
.subckt sky130_fd_sc_hd__o31ai_4 A1 A2 A3 B1 VGND VNB VPB VPWR Y
.ends

* Black-box entry subcircuit for sky130_fd_sc_hd__o21ba_2 abstract view
.subckt sky130_fd_sc_hd__o21ba_2 A1 A2 B1_N VGND VNB VPB VPWR X
.ends

* Black-box entry subcircuit for sky130_fd_sc_hd__or2_4 abstract view
.subckt sky130_fd_sc_hd__or2_4 A B VGND VNB VPB VPWR X
.ends

* Black-box entry subcircuit for sky130_fd_sc_hd__a211oi_2 abstract view
.subckt sky130_fd_sc_hd__a211oi_2 A1 A2 B1 C1 VGND VNB VPB VPWR Y
.ends

* Black-box entry subcircuit for sky130_fd_sc_hd__a21bo_2 abstract view
.subckt sky130_fd_sc_hd__a21bo_2 A1 A2 B1_N VGND VNB VPB VPWR X
.ends

* Black-box entry subcircuit for sky130_fd_sc_hd__a31oi_2 abstract view
.subckt sky130_fd_sc_hd__a31oi_2 A1 A2 A3 B1 VGND VNB VPB VPWR Y
.ends

* Black-box entry subcircuit for sky130_fd_sc_hd__a21oi_2 abstract view
.subckt sky130_fd_sc_hd__a21oi_2 A1 A2 B1 VGND VNB VPB VPWR Y
.ends

* Black-box entry subcircuit for sky130_fd_sc_hd__o211a_2 abstract view
.subckt sky130_fd_sc_hd__o211a_2 A1 A2 B1 C1 VGND VNB VPB VPWR X
.ends

* Black-box entry subcircuit for sky130_fd_sc_hd__or2b_2 abstract view
.subckt sky130_fd_sc_hd__or2b_2 A B_N VGND VNB VPB VPWR X
.ends

* Black-box entry subcircuit for sky130_fd_sc_hd__a32o_2 abstract view
.subckt sky130_fd_sc_hd__a32o_2 A1 A2 A3 B1 B2 VGND VNB VPB VPWR X
.ends

* Black-box entry subcircuit for sky130_fd_sc_hd__a2bb2o_2 abstract view
.subckt sky130_fd_sc_hd__a2bb2o_2 A1_N A2_N B1 B2 VGND VNB VPB VPWR X
.ends

* Black-box entry subcircuit for sky130_fd_sc_hd__xor2_4 abstract view
.subckt sky130_fd_sc_hd__xor2_4 A B VGND VNB VPB VPWR X
.ends

* Black-box entry subcircuit for sky130_fd_sc_hd__buf_1 abstract view
.subckt sky130_fd_sc_hd__buf_1 A VGND VNB VPB VPWR X
.ends

* Black-box entry subcircuit for sky130_fd_sc_hd__a21boi_2 abstract view
.subckt sky130_fd_sc_hd__a21boi_2 A1 A2 B1_N VGND VNB VPB VPWR Y
.ends

* Black-box entry subcircuit for sky130_fd_sc_hd__and2_4 abstract view
.subckt sky130_fd_sc_hd__and2_4 A B VGND VNB VPB VPWR X
.ends

* Black-box entry subcircuit for sky130_fd_sc_hd__o2111a_2 abstract view
.subckt sky130_fd_sc_hd__o2111a_2 A1 A2 B1 C1 D1 VGND VNB VPB VPWR X
.ends

* Black-box entry subcircuit for sky130_fd_sc_hd__and4_4 abstract view
.subckt sky130_fd_sc_hd__and4_4 A B C D VGND VNB VPB VPWR X
.ends

* Black-box entry subcircuit for sky130_fd_sc_hd__o31ai_2 abstract view
.subckt sky130_fd_sc_hd__o31ai_2 A1 A2 A3 B1 VGND VNB VPB VPWR Y
.ends

* Black-box entry subcircuit for sky130_fd_sc_hd__o311a_2 abstract view
.subckt sky130_fd_sc_hd__o311a_2 A1 A2 A3 B1 C1 VGND VNB VPB VPWR X
.ends

* Black-box entry subcircuit for sky130_fd_sc_hd__clkinv_2 abstract view
.subckt sky130_fd_sc_hd__clkinv_2 A VGND VNB VPB VPWR Y
.ends

* Black-box entry subcircuit for sky130_fd_sc_hd__a31o_4 abstract view
.subckt sky130_fd_sc_hd__a31o_4 A1 A2 A3 B1 VGND VNB VPB VPWR X
.ends

* Black-box entry subcircuit for sky130_fd_sc_hd__clkbuf_1 abstract view
.subckt sky130_fd_sc_hd__clkbuf_1 A VGND VNB VPB VPWR X
.ends

* Black-box entry subcircuit for sky130_fd_sc_hd__inv_4 abstract view
.subckt sky130_fd_sc_hd__inv_4 A VGND VNB VPB VPWR Y
.ends

* Black-box entry subcircuit for sky130_fd_sc_hd__nor2_4 abstract view
.subckt sky130_fd_sc_hd__nor2_4 A B VGND VNB VPB VPWR Y
.ends

* Black-box entry subcircuit for sky130_fd_sc_hd__clkbuf_8 abstract view
.subckt sky130_fd_sc_hd__clkbuf_8 A VGND VNB VPB VPWR X
.ends

* Black-box entry subcircuit for sky130_fd_sc_hd__a221oi_2 abstract view
.subckt sky130_fd_sc_hd__a221oi_2 A1 A2 B1 B2 C1 VGND VNB VPB VPWR Y
.ends

* Black-box entry subcircuit for sky130_fd_sc_hd__and3b_2 abstract view
.subckt sky130_fd_sc_hd__and3b_2 A_N B C VGND VNB VPB VPWR X
.ends

* Black-box entry subcircuit for sky130_fd_sc_hd__nand3b_2 abstract view
.subckt sky130_fd_sc_hd__nand3b_2 A_N B C VGND VNB VPB VPWR Y
.ends

* Black-box entry subcircuit for sky130_fd_sc_hd__clkbuf_2 abstract view
.subckt sky130_fd_sc_hd__clkbuf_2 A VGND VNB VPB VPWR X
.ends

* Black-box entry subcircuit for sky130_fd_sc_hd__or3_4 abstract view
.subckt sky130_fd_sc_hd__or3_4 A B C VGND VNB VPB VPWR X
.ends

* Black-box entry subcircuit for sky130_fd_sc_hd__nor4b_2 abstract view
.subckt sky130_fd_sc_hd__nor4b_2 A B C D_N VGND VNB VPB VPWR Y
.ends

* Black-box entry subcircuit for sky130_fd_sc_hd__a21oi_4 abstract view
.subckt sky130_fd_sc_hd__a21oi_4 A1 A2 B1 VGND VNB VPB VPWR Y
.ends

* Black-box entry subcircuit for sky130_fd_sc_hd__o221ai_2 abstract view
.subckt sky130_fd_sc_hd__o221ai_2 A1 A2 B1 B2 C1 VGND VNB VPB VPWR Y
.ends

* Black-box entry subcircuit for sky130_fd_sc_hd__nand2b_4 abstract view
.subckt sky130_fd_sc_hd__nand2b_4 A_N B VGND VNB VPB VPWR Y
.ends

* Black-box entry subcircuit for sky130_fd_sc_hd__a2111o_2 abstract view
.subckt sky130_fd_sc_hd__a2111o_2 A1 A2 B1 C1 D1 VGND VNB VPB VPWR X
.ends

* Black-box entry subcircuit for sky130_fd_sc_hd__mux4_2 abstract view
.subckt sky130_fd_sc_hd__mux4_2 A0 A1 A2 A3 S0 S1 VGND VNB VPB VPWR X
.ends

* Black-box entry subcircuit for sky130_fd_sc_hd__buf_4 abstract view
.subckt sky130_fd_sc_hd__buf_4 A VGND VNB VPB VPWR X
.ends

* Black-box entry subcircuit for sky130_fd_sc_hd__dfstp_2 abstract view
.subckt sky130_fd_sc_hd__dfstp_2 CLK D SET_B VGND VNB VPB VPWR Q
.ends

* Black-box entry subcircuit for sky130_fd_sc_hd__nor2b_2 abstract view
.subckt sky130_fd_sc_hd__nor2b_2 A B_N VGND VNB VPB VPWR Y
.ends

* Black-box entry subcircuit for sky130_fd_sc_hd__or4_2 abstract view
.subckt sky130_fd_sc_hd__or4_2 A B C D VGND VNB VPB VPWR X
.ends

* Black-box entry subcircuit for sky130_fd_sc_hd__and4_2 abstract view
.subckt sky130_fd_sc_hd__and4_2 A B C D VGND VNB VPB VPWR X
.ends

* Black-box entry subcircuit for sky130_fd_sc_hd__bufinv_16 abstract view
.subckt sky130_fd_sc_hd__bufinv_16 A VGND VNB VPB VPWR Y
.ends

* Black-box entry subcircuit for sky130_fd_sc_hd__a311oi_2 abstract view
.subckt sky130_fd_sc_hd__a311oi_2 A1 A2 A3 B1 C1 VGND VNB VPB VPWR Y
.ends

* Black-box entry subcircuit for sky130_fd_sc_hd__o21a_4 abstract view
.subckt sky130_fd_sc_hd__o21a_4 A1 A2 B1 VGND VNB VPB VPWR X
.ends

* Black-box entry subcircuit for sky130_fd_sc_hd__a41o_2 abstract view
.subckt sky130_fd_sc_hd__a41o_2 A1 A2 A3 A4 B1 VGND VNB VPB VPWR X
.ends

* Black-box entry subcircuit for sky130_fd_sc_hd__nand4bb_2 abstract view
.subckt sky130_fd_sc_hd__nand4bb_2 A_N B_N C D VGND VNB VPB VPWR Y
.ends

* Black-box entry subcircuit for sky130_fd_sc_hd__o21bai_2 abstract view
.subckt sky130_fd_sc_hd__o21bai_2 A1 A2 B1_N VGND VNB VPB VPWR Y
.ends

* Black-box entry subcircuit for sky130_fd_sc_hd__nand2_4 abstract view
.subckt sky130_fd_sc_hd__nand2_4 A B VGND VNB VPB VPWR Y
.ends

* Black-box entry subcircuit for sky130_fd_sc_hd__mux2_4 abstract view
.subckt sky130_fd_sc_hd__mux2_4 A0 A1 S VGND VNB VPB VPWR X
.ends

* Black-box entry subcircuit for sky130_fd_sc_hd__o211ai_4 abstract view
.subckt sky130_fd_sc_hd__o211ai_4 A1 A2 B1 C1 VGND VNB VPB VPWR Y
.ends

* Black-box entry subcircuit for sky130_fd_sc_hd__and4bb_4 abstract view
.subckt sky130_fd_sc_hd__and4bb_4 A_N B_N C D VGND VNB VPB VPWR X
.ends

* Black-box entry subcircuit for sky130_fd_sc_hd__o21ai_4 abstract view
.subckt sky130_fd_sc_hd__o21ai_4 A1 A2 B1 VGND VNB VPB VPWR Y
.ends

* Black-box entry subcircuit for sky130_fd_sc_hd__nand2b_2 abstract view
.subckt sky130_fd_sc_hd__nand2b_2 A_N B VGND VNB VPB VPWR Y
.ends

* Black-box entry subcircuit for sky130_fd_sc_hd__o211a_4 abstract view
.subckt sky130_fd_sc_hd__o211a_4 A1 A2 B1 C1 VGND VNB VPB VPWR X
.ends

* Black-box entry subcircuit for sky130_fd_sc_hd__or4b_4 abstract view
.subckt sky130_fd_sc_hd__or4b_4 A B C D_N VGND VNB VPB VPWR X
.ends

* Black-box entry subcircuit for sky130_fd_sc_hd__inv_6 abstract view
.subckt sky130_fd_sc_hd__inv_6 A VGND VNB VPB VPWR Y
.ends

* Black-box entry subcircuit for sky130_fd_sc_hd__nor2_1 abstract view
.subckt sky130_fd_sc_hd__nor2_1 A B VGND VNB VPB VPWR Y
.ends

* Black-box entry subcircuit for sky130_fd_sc_hd__nor4bb_2 abstract view
.subckt sky130_fd_sc_hd__nor4bb_2 A B C_N D_N VGND VNB VPB VPWR Y
.ends

* Black-box entry subcircuit for sky130_fd_sc_hd__and4b_4 abstract view
.subckt sky130_fd_sc_hd__and4b_4 A_N B C D VGND VNB VPB VPWR X
.ends

* Black-box entry subcircuit for sky130_fd_sc_hd__nor3b_2 abstract view
.subckt sky130_fd_sc_hd__nor3b_2 A B C_N VGND VNB VPB VPWR Y
.ends

* Black-box entry subcircuit for sky130_fd_sc_hd__clkbuf_4 abstract view
.subckt sky130_fd_sc_hd__clkbuf_4 A VGND VNB VPB VPWR X
.ends

* Black-box entry subcircuit for sky130_fd_sc_hd__a22oi_2 abstract view
.subckt sky130_fd_sc_hd__a22oi_2 A1 A2 B1 B2 VGND VNB VPB VPWR Y
.ends

* Black-box entry subcircuit for sky130_fd_sc_hd__a311o_2 abstract view
.subckt sky130_fd_sc_hd__a311o_2 A1 A2 A3 B1 C1 VGND VNB VPB VPWR X
.ends

* Black-box entry subcircuit for sky130_fd_sc_hd__nand4b_4 abstract view
.subckt sky130_fd_sc_hd__nand4b_4 A_N B C D VGND VNB VPB VPWR Y
.ends

* Black-box entry subcircuit for sky130_fd_sc_hd__a2bb2o_4 abstract view
.subckt sky130_fd_sc_hd__a2bb2o_4 A1_N A2_N B1 B2 VGND VNB VPB VPWR X
.ends

* Black-box entry subcircuit for sky130_fd_sc_hd__nor4_1 abstract view
.subckt sky130_fd_sc_hd__nor4_1 A B C D VGND VNB VPB VPWR Y
.ends

.subckt single_cycle_cpu VGND VPWR alu_result_out[0] alu_result_out[10] alu_result_out[11]
+ alu_result_out[12] alu_result_out[13] alu_result_out[14] alu_result_out[15] alu_result_out[16]
+ alu_result_out[17] alu_result_out[18] alu_result_out[19] alu_result_out[1] alu_result_out[20]
+ alu_result_out[21] alu_result_out[22] alu_result_out[23] alu_result_out[24] alu_result_out[25]
+ alu_result_out[26] alu_result_out[27] alu_result_out[28] alu_result_out[29] alu_result_out[2]
+ alu_result_out[30] alu_result_out[31] alu_result_out[3] alu_result_out[4] alu_result_out[5]
+ alu_result_out[6] alu_result_out[7] alu_result_out[8] alu_result_out[9] clk instruction_out[0]
+ instruction_out[10] instruction_out[11] instruction_out[12] instruction_out[13]
+ instruction_out[14] instruction_out[15] instruction_out[16] instruction_out[17]
+ instruction_out[18] instruction_out[19] instruction_out[1] instruction_out[20] instruction_out[21]
+ instruction_out[22] instruction_out[23] instruction_out[24] instruction_out[25]
+ instruction_out[26] instruction_out[27] instruction_out[28] instruction_out[29]
+ instruction_out[2] instruction_out[30] instruction_out[31] instruction_out[3] instruction_out[4]
+ instruction_out[5] instruction_out[6] instruction_out[7] instruction_out[8] instruction_out[9]
+ pc_out[0] pc_out[10] pc_out[11] pc_out[12] pc_out[13] pc_out[14] pc_out[15] pc_out[16]
+ pc_out[17] pc_out[18] pc_out[19] pc_out[1] pc_out[20] pc_out[21] pc_out[22] pc_out[23]
+ pc_out[24] pc_out[25] pc_out[26] pc_out[27] pc_out[28] pc_out[29] pc_out[2] pc_out[30]
+ pc_out[31] pc_out[3] pc_out[4] pc_out[5] pc_out[6] pc_out[7] pc_out[8] pc_out[9]
+ reset
XFILLER_100_127 VGND VGND VPWR VPWR sky130_fd_sc_hd__decap_3
XFILLER_79_380 VGND VGND VPWR VPWR sky130_fd_sc_hd__decap_3
XFILLER_27_417 VGND VGND VPWR VPWR sky130_fd_sc_hd__fill_1
XFILLER_39_255 VGND VGND VPWR VPWR sky130_fd_sc_hd__decap_3
XFILLER_67_564 VGND VGND VPWR VPWR sky130_fd_sc_hd__decap_3
XFILLER_67_586 VGND VGND VPWR VPWR sky130_fd_sc_hd__decap_3
XFILLER_82_501 VGND VGND VPWR VPWR sky130_fd_sc_hd__decap_3
XFILLER_94_394 VGND VGND VPWR VPWR sky130_fd_sc_hd__decap_3
X_6914_ _7387_/CLK _6914_/D VGND VGND VPWR VPWR _6914_/Q sky130_fd_sc_hd__dfxtp_2
XFILLER_22_100 VGND VGND VPWR VPWR sky130_fd_sc_hd__decap_3
XFILLER_82_589 VGND VGND VPWR VPWR sky130_fd_sc_hd__decap_3
XFILLER_22_133 VGND VGND VPWR VPWR sky130_fd_sc_hd__decap_3
XFILLER_52_18 VGND VGND VPWR VPWR sky130_fd_sc_hd__decap_3
XFILLER_52_29 VGND VGND VPWR VPWR sky130_fd_sc_hd__decap_3
XFILLER_62_291 VGND VGND VPWR VPWR sky130_fd_sc_hd__decap_3
X_6845_ _6977_/CLK _6845_/D VGND VGND VPWR VPWR _6845_/Q sky130_fd_sc_hd__dfxtp_2
XTAP_TAPCELL_ROW_81_1226 VGND VPWR sky130_fd_sc_hd__tapvpwrvgnd_1
XFILLER_10_306 VGND VGND VPWR VPWR sky130_fd_sc_hd__fill_2
XFILLER_22_144 VGND VGND VPWR VPWR sky130_fd_sc_hd__decap_3
XFILLER_22_155 VGND VGND VPWR VPWR sky130_fd_sc_hd__decap_3
XFILLER_50_475 VGND VGND VPWR VPWR sky130_fd_sc_hd__fill_1
X_6776_ _6976_/CLK _6776_/D VGND VGND VPWR VPWR _6776_/Q sky130_fd_sc_hd__dfxtp_2
XTAP_TAPCELL_ROW_61_982 VGND VPWR sky130_fd_sc_hd__tapvpwrvgnd_1
XTAP_TAPCELL_ROW_33_651 VGND VPWR sky130_fd_sc_hd__tapvpwrvgnd_1
X_5727_ _7369_/Q hold948/X _5737_/S VGND VGND VPWR VPWR _6713_/D sky130_fd_sc_hd__mux2_2
X_5658_ _5658_/A _5658_/B _5658_/C _5658_/D VGND VGND VPWR VPWR _5661_/C sky130_fd_sc_hd__nor4_2
XPHY_EDGE_ROW_107_Left_224 VGND VGND VPWR VPWR sky130_fd_sc_hd__decap_3
X_5589_ _5589_/A _5595_/B VGND VGND VPWR VPWR _7033_/D sky130_fd_sc_hd__or2_2
XTAP_TAPCELL_ROW_79_1199 VGND VPWR sky130_fd_sc_hd__tapvpwrvgnd_1
XFILLER_104_411 VGND VGND VPWR VPWR sky130_fd_sc_hd__decap_3
X_7328_ _7397_/CLK _7328_/D _6608_/Y VGND VGND VPWR VPWR _7328_/Q sky130_fd_sc_hd__dfrtp_2
XFILLER_2_549 VGND VGND VPWR VPWR sky130_fd_sc_hd__fill_1
XFILLER_77_15 VGND VGND VPWR VPWR sky130_fd_sc_hd__decap_3
X_7259_ _7279_/CLK _7259_/D _6539_/Y VGND VGND VPWR VPWR _7259_/Q sky130_fd_sc_hd__dfrtp_2
XTAP_TAPCELL_ROW_92_1355 VGND VPWR sky130_fd_sc_hd__tapvpwrvgnd_1
XFILLER_104_488 VGND VGND VPWR VPWR sky130_fd_sc_hd__decap_3
XFILLER_77_306 VGND VGND VPWR VPWR sky130_fd_sc_hd__decap_3
XFILLER_77_48 VGND VGND VPWR VPWR sky130_fd_sc_hd__decap_3
XFILLER_89_177 VGND VGND VPWR VPWR sky130_fd_sc_hd__decap_3
XTAP_TAPCELL_ROW_5_310 VGND VPWR sky130_fd_sc_hd__tapvpwrvgnd_1
XFILLER_58_531 VGND VGND VPWR VPWR sky130_fd_sc_hd__fill_1
XFILLER_100_672 VGND VGND VPWR VPWR sky130_fd_sc_hd__decap_3
XFILLER_92_309 VGND VGND VPWR VPWR sky130_fd_sc_hd__decap_3
Xhold1040 _7046_/Q VGND VGND VPWR VPWR _5571_/A1 sky130_fd_sc_hd__dlygate4sd3_1
Xhold1051 _7201_/Q VGND VGND VPWR VPWR _5258_/A0 sky130_fd_sc_hd__dlygate4sd3_1
XFILLER_45_225 VGND VGND VPWR VPWR sky130_fd_sc_hd__decap_3
XFILLER_73_512 VGND VGND VPWR VPWR sky130_fd_sc_hd__decap_3
XFILLER_73_545 VGND VGND VPWR VPWR sky130_fd_sc_hd__decap_3
XFILLER_93_36 VGND VGND VPWR VPWR sky130_fd_sc_hd__decap_3
Xhold1062 _7185_/Q VGND VGND VPWR VPWR _5288_/A0 sky130_fd_sc_hd__dlygate4sd3_1
Xhold1073 _7196_/Q VGND VGND VPWR VPWR _5268_/A0 sky130_fd_sc_hd__dlygate4sd3_1
Xhold1084 _7232_/Q VGND VGND VPWR VPWR _5192_/A sky130_fd_sc_hd__dlygate4sd3_1
XPHY_EDGE_ROW_116_Left_233 VGND VGND VPWR VPWR sky130_fd_sc_hd__decap_3
XFILLER_45_258 VGND VGND VPWR VPWR sky130_fd_sc_hd__decap_3
Xhold1095 _7316_/Q VGND VGND VPWR VPWR _4526_/A0 sky130_fd_sc_hd__dlygate4sd3_1
XFILLER_26_52 VGND VGND VPWR VPWR sky130_fd_sc_hd__decap_3
XFILLER_14_645 VGND VGND VPWR VPWR sky130_fd_sc_hd__fill_1
XFILLER_26_85 VGND VGND VPWR VPWR sky130_fd_sc_hd__decap_3
XFILLER_53_291 VGND VGND VPWR VPWR sky130_fd_sc_hd__decap_3
XFILLER_9_104 VGND VGND VPWR VPWR sky130_fd_sc_hd__decap_3
XFILLER_13_199 VGND VGND VPWR VPWR sky130_fd_sc_hd__decap_3
XTAP_TAPCELL_ROW_101_1462 VGND VPWR sky130_fd_sc_hd__tapvpwrvgnd_1
XTAP_TAPCELL_ROW_11_389 VGND VPWR sky130_fd_sc_hd__tapvpwrvgnd_1
XTAP_TAPCELL_ROW_11_378 VGND VPWR sky130_fd_sc_hd__tapvpwrvgnd_1
XFILLER_54_9 VGND VGND VPWR VPWR sky130_fd_sc_hd__decap_3
XFILLER_3_12 VGND VGND VPWR VPWR sky130_fd_sc_hd__decap_3
XFILLER_96_604 VGND VGND VPWR VPWR sky130_fd_sc_hd__fill_2
XFILLER_3_45 VGND VGND VPWR VPWR sky130_fd_sc_hd__decap_3
XFILLER_68_328 VGND VGND VPWR VPWR sky130_fd_sc_hd__decap_3
XFILLER_3_78 VGND VGND VPWR VPWR sky130_fd_sc_hd__decap_3
XFILLER_49_531 VGND VGND VPWR VPWR sky130_fd_sc_hd__fill_2
XFILLER_95_147 VGND VGND VPWR VPWR sky130_fd_sc_hd__decap_3
XFILLER_96_659 VGND VGND VPWR VPWR sky130_fd_sc_hd__decap_3
XTAP_TAPCELL_ROW_112_1591 VGND VPWR sky130_fd_sc_hd__tapvpwrvgnd_1
XFILLER_64_501 VGND VGND VPWR VPWR sky130_fd_sc_hd__decap_3
XFILLER_95_169 VGND VGND VPWR VPWR sky130_fd_sc_hd__decap_3
XFILLER_36_203 VGND VGND VPWR VPWR sky130_fd_sc_hd__decap_3
XFILLER_64_567 VGND VGND VPWR VPWR sky130_fd_sc_hd__fill_1
XFILLER_64_578 VGND VGND VPWR VPWR sky130_fd_sc_hd__decap_3
XFILLER_17_461 VGND VGND VPWR VPWR sky130_fd_sc_hd__fill_1
XFILLER_51_228 VGND VGND VPWR VPWR sky130_fd_sc_hd__fill_1
XFILLER_64_589 VGND VGND VPWR VPWR sky130_fd_sc_hd__fill_2
XFILLER_83_80 VGND VGND VPWR VPWR sky130_fd_sc_hd__decap_3
XFILLER_91_364 VGND VGND VPWR VPWR sky130_fd_sc_hd__decap_3
X_4960_ _4960_/A _4960_/B _4960_/C VGND VGND VPWR VPWR _4961_/C sky130_fd_sc_hd__nor3_2
XTAP_TAPCELL_ROW_19_478 VGND VPWR sky130_fd_sc_hd__tapvpwrvgnd_1
X_4891_ _3526_/B _4126_/A _4889_/Y _4811_/C _4890_/Y VGND VGND VPWR VPWR _4891_/X
+ sky130_fd_sc_hd__a221o_2
X_3911_ _6690_/Q _3913_/B1 _3917_/B1 _6868_/Q _3910_/X VGND VGND VPWR VPWR _3911_/X
+ sky130_fd_sc_hd__a221o_2
XFILLER_32_464 VGND VGND VPWR VPWR sky130_fd_sc_hd__decap_3
X_6630_ _6635_/A VGND VGND VPWR VPWR _6630_/Y sky130_fd_sc_hd__inv_2
X_3842_ _6925_/Q _3886_/A2 _3886_/B1 _6789_/Q VGND VGND VPWR VPWR _3842_/X sky130_fd_sc_hd__a22o_2
XFILLER_20_648 VGND VGND VPWR VPWR sky130_fd_sc_hd__fill_2
X_6561_ _6562_/A VGND VGND VPWR VPWR _6561_/Y sky130_fd_sc_hd__inv_2
XTAP_TAPCELL_ROW_30_610 VGND VPWR sky130_fd_sc_hd__tapvpwrvgnd_1
XFILLER_20_659 VGND VGND VPWR VPWR sky130_fd_sc_hd__fill_2
X_3773_ _6775_/Q _3879_/A2 _3889_/A2 _6763_/Q VGND VGND VPWR VPWR _3773_/X sky130_fd_sc_hd__a22o_2
X_6492_ _6647_/A VGND VGND VPWR VPWR _6492_/Y sky130_fd_sc_hd__inv_2
XFILLER_9_682 VGND VGND VPWR VPWR sky130_fd_sc_hd__fill_2
XFILLER_105_219 VGND VGND VPWR VPWR sky130_fd_sc_hd__decap_3
X_7113_ _7403_/CLK _7113_/D _6393_/Y VGND VGND VPWR VPWR _7113_/Q sky130_fd_sc_hd__dfrtp_2
Xoutput478 _5663_/B VGND VGND VPWR VPWR alu_result_out[25] sky130_fd_sc_hd__clkdlybuf4s25_1
Xoutput467 _5657_/D VGND VGND VPWR VPWR alu_result_out[15] sky130_fd_sc_hd__clkdlybuf4s25_1
X_4325_ _7354_/Q _4272_/B _4323_/X _4324_/X VGND VGND VPWR VPWR _4325_/X sky130_fd_sc_hd__a211o_2
XFILLER_99_431 VGND VGND VPWR VPWR sky130_fd_sc_hd__decap_3
XFILLER_101_414 VGND VGND VPWR VPWR sky130_fd_sc_hd__decap_3
XFILLER_113_252 VGND VGND VPWR VPWR sky130_fd_sc_hd__decap_3
XFILLER_59_317 VGND VGND VPWR VPWR sky130_fd_sc_hd__decap_3
XFILLER_87_626 VGND VGND VPWR VPWR sky130_fd_sc_hd__decap_3
Xoutput489 _3741_/B VGND VGND VPWR VPWR alu_result_out[6] sky130_fd_sc_hd__clkdlybuf4s25_1
XFILLER_99_486 VGND VGND VPWR VPWR sky130_fd_sc_hd__decap_3
XFILLER_101_447 VGND VGND VPWR VPWR sky130_fd_sc_hd__fill_1
XFILLER_113_296 VGND VGND VPWR VPWR sky130_fd_sc_hd__decap_3
XFILLER_86_147 VGND VGND VPWR VPWR sky130_fd_sc_hd__decap_3
X_7044_ _7397_/CLK _7044_/D _6324_/Y VGND VGND VPWR VPWR _7044_/Q sky130_fd_sc_hd__dfrtp_2
X_4256_ _4626_/B _4626_/C _4256_/C VGND VGND VPWR VPWR _4988_/A sky130_fd_sc_hd__and3_4
X_4187_ _7327_/Q _3949_/S _4505_/S _7295_/Q VGND VGND VPWR VPWR _4187_/X sky130_fd_sc_hd__a22o_2
XFILLER_103_24 VGND VGND VPWR VPWR sky130_fd_sc_hd__decap_3
XFILLER_27_203 VGND VGND VPWR VPWR sky130_fd_sc_hd__decap_3
XFILLER_27_225 VGND VGND VPWR VPWR sky130_fd_sc_hd__decap_3
XTAP_TAPCELL_ROW_38_710 VGND VPWR sky130_fd_sc_hd__tapvpwrvgnd_1
XFILLER_103_57 VGND VGND VPWR VPWR sky130_fd_sc_hd__decap_3
XFILLER_55_567 VGND VGND VPWR VPWR sky130_fd_sc_hd__decap_3
XFILLER_82_342 VGND VGND VPWR VPWR sky130_fd_sc_hd__decap_3
XFILLER_27_269 VGND VGND VPWR VPWR sky130_fd_sc_hd__decap_3
XFILLER_70_537 VGND VGND VPWR VPWR sky130_fd_sc_hd__decap_3
XFILLER_82_386 VGND VGND VPWR VPWR sky130_fd_sc_hd__decap_3
XFILLER_42_239 VGND VGND VPWR VPWR sky130_fd_sc_hd__decap_3
XFILLER_50_250 VGND VGND VPWR VPWR sky130_fd_sc_hd__fill_2
X_6828_ _6911_/CLK _6828_/D VGND VGND VPWR VPWR _6828_/Q sky130_fd_sc_hd__dfxtp_2
XFILLER_10_114 VGND VGND VPWR VPWR sky130_fd_sc_hd__decap_3
XFILLER_11_626 VGND VGND VPWR VPWR sky130_fd_sc_hd__decap_3
XFILLER_11_648 VGND VGND VPWR VPWR sky130_fd_sc_hd__decap_3
XFILLER_23_497 VGND VGND VPWR VPWR sky130_fd_sc_hd__decap_3
XFILLER_50_283 VGND VGND VPWR VPWR sky130_fd_sc_hd__fill_2
XFILLER_12_21 VGND VGND VPWR VPWR sky130_fd_sc_hd__decap_3
X_6759_ _6964_/CLK _6759_/D VGND VGND VPWR VPWR _6759_/Q sky130_fd_sc_hd__dfxtp_2
XFILLER_12_32 VGND VGND VPWR VPWR sky130_fd_sc_hd__decap_3
XFILLER_6_118 VGND VGND VPWR VPWR sky130_fd_sc_hd__decap_3
XFILLER_2_302 VGND VGND VPWR VPWR sky130_fd_sc_hd__fill_1
XFILLER_2_324 VGND VGND VPWR VPWR sky130_fd_sc_hd__decap_3
XFILLER_88_58 VGND VGND VPWR VPWR sky130_fd_sc_hd__decap_3
XFILLER_2_368 VGND VGND VPWR VPWR sky130_fd_sc_hd__decap_3
XFILLER_104_296 VGND VGND VPWR VPWR sky130_fd_sc_hd__decap_3
XFILLER_78_648 VGND VGND VPWR VPWR sky130_fd_sc_hd__decap_3
XFILLER_58_350 VGND VGND VPWR VPWR sky130_fd_sc_hd__decap_3
XFILLER_77_169 VGND VGND VPWR VPWR sky130_fd_sc_hd__fill_1
XFILLER_100_480 VGND VGND VPWR VPWR sky130_fd_sc_hd__decap_3
XFILLER_92_117 VGND VGND VPWR VPWR sky130_fd_sc_hd__decap_3
XFILLER_18_236 VGND VGND VPWR VPWR sky130_fd_sc_hd__decap_3
XFILLER_37_84 VGND VGND VPWR VPWR sky130_fd_sc_hd__decap_3
XFILLER_46_567 VGND VGND VPWR VPWR sky130_fd_sc_hd__decap_3
XFILLER_18_269 VGND VGND VPWR VPWR sky130_fd_sc_hd__fill_1
XFILLER_46_578 VGND VGND VPWR VPWR sky130_fd_sc_hd__decap_3
XFILLER_26_280 VGND VGND VPWR VPWR sky130_fd_sc_hd__decap_3
XFILLER_33_228 VGND VGND VPWR VPWR sky130_fd_sc_hd__decap_3
XFILLER_61_548 VGND VGND VPWR VPWR sky130_fd_sc_hd__fill_1
XTAP_TAPCELL_ROW_16_448 VGND VPWR sky130_fd_sc_hd__tapvpwrvgnd_1
XFILLER_53_72 VGND VGND VPWR VPWR sky130_fd_sc_hd__decap_3
XTAP_TAPCELL_ROW_44_779 VGND VPWR sky130_fd_sc_hd__tapvpwrvgnd_1
XFILLER_41_261 VGND VGND VPWR VPWR sky130_fd_sc_hd__decap_3
XFILLER_6_663 VGND VGND VPWR VPWR sky130_fd_sc_hd__decap_3
XFILLER_108_580 VGND VGND VPWR VPWR sky130_fd_sc_hd__decap_3
XFILLER_115_539 VGND VGND VPWR VPWR sky130_fd_sc_hd__decap_3
XFILLER_52_6 VGND VGND VPWR VPWR sky130_fd_sc_hd__decap_3
XFILLER_5_151 VGND VGND VPWR VPWR sky130_fd_sc_hd__decap_3
XTAP_TAPCELL_ROW_114_1620 VGND VPWR sky130_fd_sc_hd__tapvpwrvgnd_1
XFILLER_5_184 VGND VGND VPWR VPWR sky130_fd_sc_hd__fill_1
XFILLER_68_103 VGND VGND VPWR VPWR sky130_fd_sc_hd__decap_3
XFILLER_69_615 VGND VGND VPWR VPWR sky130_fd_sc_hd__fill_1
XFILLER_96_412 VGND VGND VPWR VPWR sky130_fd_sc_hd__decap_3
XFILLER_110_200 VGND VGND VPWR VPWR sky130_fd_sc_hd__decap_3
XFILLER_68_136 VGND VGND VPWR VPWR sky130_fd_sc_hd__decap_3
XFILLER_78_91 VGND VGND VPWR VPWR sky130_fd_sc_hd__decap_3
X_5090_ _5146_/B1 _5083_/X _5085_/X _5089_/Y VGND VGND VPWR VPWR _5658_/C sky130_fd_sc_hd__a31o_2
X_4110_ _4376_/A _4141_/A _4141_/B _4142_/C VGND VGND VPWR VPWR _4111_/B sky130_fd_sc_hd__or4_4
XFILLER_1_390 VGND VGND VPWR VPWR sky130_fd_sc_hd__fill_2
XFILLER_56_309 VGND VGND VPWR VPWR sky130_fd_sc_hd__decap_3
XFILLER_68_147 VGND VGND VPWR VPWR sky130_fd_sc_hd__decap_3
XFILLER_96_489 VGND VGND VPWR VPWR sky130_fd_sc_hd__decap_3
X_4041_ _7245_/Q _4430_/A2 _4428_/B1 _7149_/Q VGND VGND VPWR VPWR _4041_/X sky130_fd_sc_hd__a22o_2
XFILLER_37_501 VGND VGND VPWR VPWR sky130_fd_sc_hd__decap_3
XFILLER_83_128 VGND VGND VPWR VPWR sky130_fd_sc_hd__decap_3
XFILLER_37_567 VGND VGND VPWR VPWR sky130_fd_sc_hd__fill_1
XFILLER_92_640 VGND VGND VPWR VPWR sky130_fd_sc_hd__decap_3
XFILLER_92_651 VGND VGND VPWR VPWR sky130_fd_sc_hd__decap_3
XFILLER_52_504 VGND VGND VPWR VPWR sky130_fd_sc_hd__decap_3
XFILLER_91_161 VGND VGND VPWR VPWR sky130_fd_sc_hd__decap_3
XFILLER_92_684 VGND VGND VPWR VPWR sky130_fd_sc_hd__decap_3
XFILLER_24_228 VGND VGND VPWR VPWR sky130_fd_sc_hd__decap_3
X_4943_ _4943_/A _4943_/B VGND VGND VPWR VPWR _4944_/C sky130_fd_sc_hd__nor2_2
XTAP_TAPCELL_ROW_65_1029 VGND VPWR sky130_fd_sc_hd__tapvpwrvgnd_1
XFILLER_32_250 VGND VGND VPWR VPWR sky130_fd_sc_hd__fill_2
XFILLER_60_592 VGND VGND VPWR VPWR sky130_fd_sc_hd__decap_3
X_6613_ _6643_/A VGND VGND VPWR VPWR _6613_/Y sky130_fd_sc_hd__inv_2
X_4874_ _4814_/A _4849_/Y _4872_/X _4873_/X VGND VGND VPWR VPWR _4874_/X sky130_fd_sc_hd__o31a_2
X_3825_ _6749_/Q _3912_/A2 _3913_/A2 _6737_/Q VGND VGND VPWR VPWR _3825_/X sky130_fd_sc_hd__a22o_2
X_6544_ _6548_/A VGND VGND VPWR VPWR _6544_/Y sky130_fd_sc_hd__inv_2
X_3756_ _6798_/Q _3862_/B1 _3767_/A2 _6708_/Q _3755_/X VGND VGND VPWR VPWR _3756_/X
+ sky130_fd_sc_hd__a221o_2
X_6475_ _6535_/A VGND VGND VPWR VPWR _6475_/Y sky130_fd_sc_hd__inv_2
XTAP_TAPCELL_ROW_76_1158 VGND VPWR sky130_fd_sc_hd__tapvpwrvgnd_1
XTAP_TAPCELL_ROW_76_1169 VGND VPWR sky130_fd_sc_hd__tapvpwrvgnd_1
XFILLER_114_572 VGND VGND VPWR VPWR sky130_fd_sc_hd__decap_3
XFILLER_87_445 VGND VGND VPWR VPWR sky130_fd_sc_hd__decap_3
X_5288_ _5288_/A0 _3993_/X _5292_/S VGND VGND VPWR VPWR _7185_/D sky130_fd_sc_hd__mux2_2
X_4308_ _7192_/Q _3989_/S _4332_/B1 _7384_/Q VGND VGND VPWR VPWR _4308_/X sky130_fd_sc_hd__a22o_2
XFILLER_114_12 VGND VGND VPWR VPWR sky130_fd_sc_hd__decap_3
XFILLER_59_158 VGND VGND VPWR VPWR sky130_fd_sc_hd__decap_3
XFILLER_59_169 VGND VGND VPWR VPWR sky130_fd_sc_hd__decap_3
XFILLER_75_607 VGND VGND VPWR VPWR sky130_fd_sc_hd__decap_3
XFILLER_75_629 VGND VGND VPWR VPWR sky130_fd_sc_hd__decap_3
X_7027_ _7374_/CLK _7027_/D _6307_/Y VGND VGND VPWR VPWR _7027_/Q sky130_fd_sc_hd__dfrtp_2
X_4239_ _4628_/A _4629_/B VGND VGND VPWR VPWR _5018_/B sky130_fd_sc_hd__nor2_2
XFILLER_101_299 VGND VGND VPWR VPWR sky130_fd_sc_hd__decap_3
XFILLER_114_56 VGND VGND VPWR VPWR sky130_fd_sc_hd__decap_3
XFILLER_68_681 VGND VGND VPWR VPWR sky130_fd_sc_hd__decap_3
XFILLER_74_117 VGND VGND VPWR VPWR sky130_fd_sc_hd__decap_3
XFILLER_28_567 VGND VGND VPWR VPWR sky130_fd_sc_hd__decap_3
XFILLER_67_180 VGND VGND VPWR VPWR sky130_fd_sc_hd__decap_3
XFILLER_74_38 VGND VGND VPWR VPWR sky130_fd_sc_hd__decap_3
XFILLER_15_217 VGND VGND VPWR VPWR sky130_fd_sc_hd__decap_3
XFILLER_28_578 VGND VGND VPWR VPWR sky130_fd_sc_hd__fill_1
XFILLER_70_312 VGND VGND VPWR VPWR sky130_fd_sc_hd__fill_1
XFILLER_83_673 VGND VGND VPWR VPWR sky130_fd_sc_hd__decap_3
XFILLER_15_228 VGND VGND VPWR VPWR sky130_fd_sc_hd__decap_3
XFILLER_43_559 VGND VGND VPWR VPWR sky130_fd_sc_hd__fill_1
XFILLER_55_397 VGND VGND VPWR VPWR sky130_fd_sc_hd__decap_3
XTAP_TAPCELL_ROW_87_1298 VGND VPWR sky130_fd_sc_hd__tapvpwrvgnd_1
XFILLER_30_209 VGND VGND VPWR VPWR sky130_fd_sc_hd__decap_3
XFILLER_70_378 VGND VGND VPWR VPWR sky130_fd_sc_hd__decap_3
XFILLER_51_592 VGND VGND VPWR VPWR sky130_fd_sc_hd__decap_3
XFILLER_90_59 VGND VGND VPWR VPWR sky130_fd_sc_hd__fill_1
XTAP_TAPCELL_ROW_41_749 VGND VPWR sky130_fd_sc_hd__tapvpwrvgnd_1
XTAP_TAPCELL_ROW_41_738 VGND VPWR sky130_fd_sc_hd__tapvpwrvgnd_1
XTAP_TAPCELL_ROW_13_407 VGND VPWR sky130_fd_sc_hd__tapvpwrvgnd_1
XFILLER_23_75 VGND VGND VPWR VPWR sky130_fd_sc_hd__decap_3
XFILLER_7_416 VGND VGND VPWR VPWR sky130_fd_sc_hd__decap_3
XFILLER_7_449 VGND VGND VPWR VPWR sky130_fd_sc_hd__decap_3
XFILLER_109_388 VGND VGND VPWR VPWR sky130_fd_sc_hd__decap_3
XFILLER_109_399 VGND VGND VPWR VPWR sky130_fd_sc_hd__decap_3
XFILLER_99_57 VGND VGND VPWR VPWR sky130_fd_sc_hd__decap_3
XFILLER_2_121 VGND VGND VPWR VPWR sky130_fd_sc_hd__decap_3
XFILLER_3_644 VGND VGND VPWR VPWR sky130_fd_sc_hd__decap_3
XFILLER_105_561 VGND VGND VPWR VPWR sky130_fd_sc_hd__decap_3
XFILLER_112_509 VGND VGND VPWR VPWR sky130_fd_sc_hd__fill_1
XFILLER_78_445 VGND VGND VPWR VPWR sky130_fd_sc_hd__decap_3
XFILLER_38_309 VGND VGND VPWR VPWR sky130_fd_sc_hd__decap_3
XFILLER_66_607 VGND VGND VPWR VPWR sky130_fd_sc_hd__decap_3
XFILLER_17_9 VGND VGND VPWR VPWR sky130_fd_sc_hd__decap_3
XFILLER_78_489 VGND VGND VPWR VPWR sky130_fd_sc_hd__decap_3
Xsingle_cycle_cpu_579 VGND VGND VPWR VPWR instruction_out[0] single_cycle_cpu_579/LO
+ sky130_fd_sc_hd__conb_1
XTAP_TAPCELL_ROW_49_838 VGND VPWR sky130_fd_sc_hd__tapvpwrvgnd_1
XFILLER_0_35 VGND VGND VPWR VPWR sky130_fd_sc_hd__decap_3
XFILLER_58_180 VGND VGND VPWR VPWR sky130_fd_sc_hd__decap_3
XFILLER_0_68 VGND VGND VPWR VPWR sky130_fd_sc_hd__decap_3
XFILLER_74_684 VGND VGND VPWR VPWR sky130_fd_sc_hd__decap_3
XFILLER_46_397 VGND VGND VPWR VPWR sky130_fd_sc_hd__decap_3
XFILLER_61_323 VGND VGND VPWR VPWR sky130_fd_sc_hd__decap_3
XFILLER_64_71 VGND VGND VPWR VPWR sky130_fd_sc_hd__decap_3
XFILLER_73_172 VGND VGND VPWR VPWR sky130_fd_sc_hd__decap_3
XFILLER_73_183 VGND VGND VPWR VPWR sky130_fd_sc_hd__decap_3
XTAP_TAPCELL_ROW_29_595 VGND VPWR sky130_fd_sc_hd__tapvpwrvgnd_1
XFILLER_14_272 VGND VGND VPWR VPWR sky130_fd_sc_hd__fill_1
XFILLER_42_592 VGND VGND VPWR VPWR sky130_fd_sc_hd__decap_3
XFILLER_9_33 VGND VGND VPWR VPWR sky130_fd_sc_hd__decap_3
XFILLER_9_66 VGND VGND VPWR VPWR sky130_fd_sc_hd__decap_3
X_3610_ _3610_/A _3610_/B VGND VGND VPWR VPWR _3610_/Y sky130_fd_sc_hd__nor2_2
XPHY_EDGE_ROW_104_Right_104 VGND VGND VPWR VPWR sky130_fd_sc_hd__decap_3
X_3541_ _4376_/A _3541_/B _4460_/B VGND VGND VPWR VPWR _3541_/X sky130_fd_sc_hd__or3b_4
XFILLER_115_314 VGND VGND VPWR VPWR sky130_fd_sc_hd__fill_1
Xhold906 _6706_/Q VGND VGND VPWR VPWR hold906/X sky130_fd_sc_hd__dlygate4sd3_1
Xhold917 _6689_/Q VGND VGND VPWR VPWR hold917/X sky130_fd_sc_hd__dlygate4sd3_1
Xhold928 _7025_/Q VGND VGND VPWR VPWR _5605_/A sky130_fd_sc_hd__dlygate4sd3_1
Xhold939 _7311_/Q VGND VGND VPWR VPWR hold939/X sky130_fd_sc_hd__dlygate4sd3_1
X_6260_ _6385_/A VGND VGND VPWR VPWR _6260_/Y sky130_fd_sc_hd__inv_2
X_3472_ _7216_/Q _3377_/X _4235_/B1 _7120_/Q VGND VGND VPWR VPWR _3472_/X sky130_fd_sc_hd__a22o_2
XFILLER_88_209 VGND VGND VPWR VPWR sky130_fd_sc_hd__decap_3
XFILLER_89_90 VGND VGND VPWR VPWR sky130_fd_sc_hd__decap_3
X_5211_ _5211_/A _5225_/B VGND VGND VPWR VPWR _7223_/D sky130_fd_sc_hd__and2_2
XFILLER_111_520 VGND VGND VPWR VPWR sky130_fd_sc_hd__decap_3
XFILLER_69_412 VGND VGND VPWR VPWR sky130_fd_sc_hd__decap_3
X_5142_ _5142_/A0 _3993_/X _5159_/S VGND VGND VPWR VPWR _7249_/D sky130_fd_sc_hd__mux2_2
XFILLER_96_231 VGND VGND VPWR VPWR sky130_fd_sc_hd__decap_3
XFILLER_96_253 VGND VGND VPWR VPWR sky130_fd_sc_hd__decap_3
XFILLER_111_597 VGND VGND VPWR VPWR sky130_fd_sc_hd__decap_3
XFILLER_57_629 VGND VGND VPWR VPWR sky130_fd_sc_hd__decap_3
X_5073_ _5073_/A _5073_/B VGND VGND VPWR VPWR _5073_/Y sky130_fd_sc_hd__xnor2_2
XTAP_TAPCELL_ROW_71_1099 VGND VPWR sky130_fd_sc_hd__tapvpwrvgnd_1
XFILLER_37_331 VGND VGND VPWR VPWR sky130_fd_sc_hd__decap_3
XFILLER_49_180 VGND VGND VPWR VPWR sky130_fd_sc_hd__decap_3
XFILLER_84_448 VGND VGND VPWR VPWR sky130_fd_sc_hd__decap_3
XFILLER_52_301 VGND VGND VPWR VPWR sky130_fd_sc_hd__decap_3
XFILLER_65_662 VGND VGND VPWR VPWR sky130_fd_sc_hd__decap_3
XFILLER_65_673 VGND VGND VPWR VPWR sky130_fd_sc_hd__decap_3
XFILLER_52_312 VGND VGND VPWR VPWR sky130_fd_sc_hd__decap_3
XFILLER_64_172 VGND VGND VPWR VPWR sky130_fd_sc_hd__fill_2
XFILLER_92_492 VGND VGND VPWR VPWR sky130_fd_sc_hd__decap_3
XFILLER_12_209 VGND VGND VPWR VPWR sky130_fd_sc_hd__decap_3
XFILLER_52_345 VGND VGND VPWR VPWR sky130_fd_sc_hd__decap_3
XFILLER_80_687 VGND VGND VPWR VPWR sky130_fd_sc_hd__decap_3
X_4926_ _4948_/A _4920_/Y _4925_/X VGND VGND VPWR VPWR _5656_/C sky130_fd_sc_hd__o21ai_2
XFILLER_100_47 VGND VGND VPWR VPWR sky130_fd_sc_hd__decap_3
X_4857_ _5015_/A _5655_/D wire552/X VGND VGND VPWR VPWR _4857_/X sky130_fd_sc_hd__or3b_4
XFILLER_20_253 VGND VGND VPWR VPWR sky130_fd_sc_hd__decap_3
XFILLER_20_275 VGND VGND VPWR VPWR sky130_fd_sc_hd__fill_1
XFILLER_60_29 VGND VGND VPWR VPWR sky130_fd_sc_hd__decap_3
X_3808_ _6929_/Q _3884_/A2 _3913_/A2 _6793_/Q _3807_/X VGND VGND VPWR VPWR _3808_/X
+ sky130_fd_sc_hd__a221o_2
XFILLER_109_12 VGND VGND VPWR VPWR sky130_fd_sc_hd__decap_3
X_6527_ _6637_/A VGND VGND VPWR VPWR _6527_/Y sky130_fd_sc_hd__inv_2
X_4788_ _4788_/A _4788_/B VGND VGND VPWR VPWR _4788_/Y sky130_fd_sc_hd__nand2_2
XFILLER_109_45 VGND VGND VPWR VPWR sky130_fd_sc_hd__decap_3
XFILLER_4_408 VGND VGND VPWR VPWR sky130_fd_sc_hd__decap_3
X_3739_ _6936_/Q _3912_/A2 _3913_/A2 _6800_/Q VGND VGND VPWR VPWR _3739_/X sky130_fd_sc_hd__a22o_2
XFILLER_106_336 VGND VGND VPWR VPWR sky130_fd_sc_hd__decap_3
XFILLER_109_78 VGND VGND VPWR VPWR sky130_fd_sc_hd__decap_3
X_6458_ _6682_/A VGND VGND VPWR VPWR _6458_/Y sky130_fd_sc_hd__inv_2
X_6389_ _6611_/A VGND VGND VPWR VPWR _6389_/Y sky130_fd_sc_hd__inv_2
X_5409_ _5409_/A0 _5079_/X _5417_/S VGND VGND VPWR VPWR _7129_/D sky130_fd_sc_hd__mux2_2
XFILLER_0_614 VGND VGND VPWR VPWR sky130_fd_sc_hd__fill_2
XFILLER_102_531 VGND VGND VPWR VPWR sky130_fd_sc_hd__fill_1
XFILLER_102_542 VGND VGND VPWR VPWR sky130_fd_sc_hd__decap_3
XFILLER_48_618 VGND VGND VPWR VPWR sky130_fd_sc_hd__decap_3
XFILLER_85_26 VGND VGND VPWR VPWR sky130_fd_sc_hd__decap_3
XFILLER_102_586 VGND VGND VPWR VPWR sky130_fd_sc_hd__fill_2
XFILLER_75_426 VGND VGND VPWR VPWR sky130_fd_sc_hd__decap_3
XFILLER_87_264 VGND VGND VPWR VPWR sky130_fd_sc_hd__decap_3
XTAP_TAPCELL_ROW_89_1316 VGND VPWR sky130_fd_sc_hd__tapvpwrvgnd_1
XFILLER_18_53 VGND VGND VPWR VPWR sky130_fd_sc_hd__decap_3
XFILLER_56_651 VGND VGND VPWR VPWR sky130_fd_sc_hd__decap_3
XFILLER_55_161 VGND VGND VPWR VPWR sky130_fd_sc_hd__decap_3
XFILLER_56_684 VGND VGND VPWR VPWR sky130_fd_sc_hd__decap_3
XFILLER_90_418 VGND VGND VPWR VPWR sky130_fd_sc_hd__fill_2
XTAP_TAPCELL_ROW_46_808 VGND VPWR sky130_fd_sc_hd__tapvpwrvgnd_1
XFILLER_18_97 VGND VGND VPWR VPWR sky130_fd_sc_hd__decap_3
XFILLER_43_323 VGND VGND VPWR VPWR sky130_fd_sc_hd__decap_3
XFILLER_55_172 VGND VGND VPWR VPWR sky130_fd_sc_hd__decap_3
XFILLER_55_183 VGND VGND VPWR VPWR sky130_fd_sc_hd__decap_3
XFILLER_71_632 VGND VGND VPWR VPWR sky130_fd_sc_hd__decap_3
XFILLER_16_559 VGND VGND VPWR VPWR sky130_fd_sc_hd__decap_3
XFILLER_70_131 VGND VGND VPWR VPWR sky130_fd_sc_hd__decap_3
XFILLER_71_665 VGND VGND VPWR VPWR sky130_fd_sc_hd__decap_3
XFILLER_71_676 VGND VGND VPWR VPWR sky130_fd_sc_hd__decap_3
XFILLER_34_63 VGND VGND VPWR VPWR sky130_fd_sc_hd__decap_3
XFILLER_43_389 VGND VGND VPWR VPWR sky130_fd_sc_hd__decap_3
XFILLER_70_164 VGND VGND VPWR VPWR sky130_fd_sc_hd__fill_2
XFILLER_70_175 VGND VGND VPWR VPWR sky130_fd_sc_hd__decap_3
XTAP_TAPCELL_ROW_54_896 VGND VPWR sky130_fd_sc_hd__tapvpwrvgnd_1
XTAP_TAPCELL_ROW_26_565 VGND VPWR sky130_fd_sc_hd__tapvpwrvgnd_1
XFILLER_11_220 VGND VGND VPWR VPWR sky130_fd_sc_hd__decap_3
XFILLER_11_231 VGND VGND VPWR VPWR sky130_fd_sc_hd__decap_3
XFILLER_34_85 VGND VGND VPWR VPWR sky130_fd_sc_hd__decap_3
XFILLER_70_197 VGND VGND VPWR VPWR sky130_fd_sc_hd__decap_3
XFILLER_11_275 VGND VGND VPWR VPWR sky130_fd_sc_hd__decap_3
XFILLER_109_141 VGND VGND VPWR VPWR sky130_fd_sc_hd__decap_3
XFILLER_7_246 VGND VGND VPWR VPWR sky130_fd_sc_hd__decap_3
XFILLER_50_62 VGND VGND VPWR VPWR sky130_fd_sc_hd__decap_3
XFILLER_112_306 VGND VGND VPWR VPWR sky130_fd_sc_hd__fill_2
XFILLER_3_441 VGND VGND VPWR VPWR sky130_fd_sc_hd__decap_3
XFILLER_59_60 VGND VGND VPWR VPWR sky130_fd_sc_hd__decap_3
XFILLER_59_71 VGND VGND VPWR VPWR sky130_fd_sc_hd__decap_3
XFILLER_59_93 VGND VGND VPWR VPWR sky130_fd_sc_hd__decap_3
XFILLER_78_231 VGND VGND VPWR VPWR sky130_fd_sc_hd__fill_1
XFILLER_66_415 VGND VGND VPWR VPWR sky130_fd_sc_hd__decap_3
XFILLER_66_437 VGND VGND VPWR VPWR sky130_fd_sc_hd__decap_3
XFILLER_78_275 VGND VGND VPWR VPWR sky130_fd_sc_hd__decap_3
XFILLER_15_6 VGND VGND VPWR VPWR sky130_fd_sc_hd__decap_3
XFILLER_93_234 VGND VGND VPWR VPWR sky130_fd_sc_hd__decap_3
XFILLER_47_662 VGND VGND VPWR VPWR sky130_fd_sc_hd__decap_3
XFILLER_47_673 VGND VGND VPWR VPWR sky130_fd_sc_hd__decap_3
XFILLER_53_109 VGND VGND VPWR VPWR sky130_fd_sc_hd__decap_3
XFILLER_75_81 VGND VGND VPWR VPWR sky130_fd_sc_hd__decap_3
XTAP_TAPCELL_ROW_109_1563 VGND VPWR sky130_fd_sc_hd__tapvpwrvgnd_1
XFILLER_19_386 VGND VGND VPWR VPWR sky130_fd_sc_hd__decap_3
XFILLER_34_312 VGND VGND VPWR VPWR sky130_fd_sc_hd__decap_3
XFILLER_46_183 VGND VGND VPWR VPWR sky130_fd_sc_hd__decap_3
XFILLER_62_632 VGND VGND VPWR VPWR sky130_fd_sc_hd__decap_3
XFILLER_34_345 VGND VGND VPWR VPWR sky130_fd_sc_hd__decap_3
XFILLER_61_153 VGND VGND VPWR VPWR sky130_fd_sc_hd__decap_3
XFILLER_62_654 VGND VGND VPWR VPWR sky130_fd_sc_hd__decap_3
XFILLER_15_570 VGND VGND VPWR VPWR sky130_fd_sc_hd__decap_3
XFILLER_61_175 VGND VGND VPWR VPWR sky130_fd_sc_hd__decap_3
XFILLER_62_687 VGND VGND VPWR VPWR sky130_fd_sc_hd__decap_3
XFILLER_98_3 VGND VGND VPWR VPWR sky130_fd_sc_hd__decap_3
X_4711_ _7005_/Q _7006_/Q _4775_/A VGND VGND VPWR VPWR _4738_/A sky130_fd_sc_hd__and3_2
X_4642_ _4207_/A _4642_/B VGND VGND VPWR VPWR _4888_/A sky130_fd_sc_hd__and2b_2
XFILLER_116_612 VGND VGND VPWR VPWR sky130_fd_sc_hd__decap_3
XFILLER_116_623 VGND VGND VPWR VPWR sky130_fd_sc_hd__decap_3
X_7361_ _7368_/CLK _7361_/D _6641_/Y VGND VGND VPWR VPWR _7361_/Q sky130_fd_sc_hd__dfrtp_2
Xhold703 _6778_/Q VGND VGND VPWR VPWR _6778_/D sky130_fd_sc_hd__dlygate4sd3_1
X_4573_ _7294_/Q _4577_/B VGND VGND VPWR VPWR _7294_/D sky130_fd_sc_hd__and2_2
XFILLER_115_111 VGND VGND VPWR VPWR sky130_fd_sc_hd__fill_1
XFILLER_115_122 VGND VGND VPWR VPWR sky130_fd_sc_hd__decap_3
XFILLER_116_645 VGND VGND VPWR VPWR sky130_fd_sc_hd__decap_3
X_7292_ _7358_/CLK _7292_/D _6572_/Y VGND VGND VPWR VPWR _7292_/Q sky130_fd_sc_hd__dfrtp_2
Xhold714 _6782_/Q VGND VGND VPWR VPWR _6782_/D sky130_fd_sc_hd__dlygate4sd3_1
Xhold725 _6721_/Q VGND VGND VPWR VPWR _6721_/D sky130_fd_sc_hd__dlygate4sd3_1
Xhold736 _6871_/Q VGND VGND VPWR VPWR _6871_/D sky130_fd_sc_hd__dlygate4sd3_1
X_6312_ _6634_/A VGND VGND VPWR VPWR _6312_/Y sky130_fd_sc_hd__inv_2
XFILLER_115_155 VGND VGND VPWR VPWR sky130_fd_sc_hd__decap_3
Xhold747 _6838_/Q VGND VGND VPWR VPWR _6838_/D sky130_fd_sc_hd__dlygate4sd3_1
Xhold758 _6736_/Q VGND VGND VPWR VPWR _6736_/D sky130_fd_sc_hd__dlygate4sd3_1
Xhold769 _6745_/Q VGND VGND VPWR VPWR _6745_/D sky130_fd_sc_hd__dlygate4sd3_1
X_3455_ _7346_/Q _3449_/X _3454_/X VGND VGND VPWR VPWR _3455_/X sky130_fd_sc_hd__a21o_2
XTAP_TAPCELL_ROW_73_1128 VGND VPWR sky130_fd_sc_hd__tapvpwrvgnd_1
XFILLER_115_199 VGND VGND VPWR VPWR sky130_fd_sc_hd__decap_3
XFILLER_69_231 VGND VGND VPWR VPWR sky130_fd_sc_hd__decap_3
X_3386_ _6982_/Q _3386_/B VGND VGND VPWR VPWR _3386_/Y sky130_fd_sc_hd__nand2_2
XFILLER_111_361 VGND VGND VPWR VPWR sky130_fd_sc_hd__decap_3
XFILLER_69_275 VGND VGND VPWR VPWR sky130_fd_sc_hd__decap_3
XFILLER_84_212 VGND VGND VPWR VPWR sky130_fd_sc_hd__decap_3
X_5125_ _5156_/S _5125_/B VGND VGND VPWR VPWR _5125_/Y sky130_fd_sc_hd__nand2_2
XFILLER_29_128 VGND VGND VPWR VPWR sky130_fd_sc_hd__decap_3
XFILLER_29_139 VGND VGND VPWR VPWR sky130_fd_sc_hd__decap_3
X_5056_ _3536_/B _4619_/B _5052_/X _5055_/X VGND VGND VPWR VPWR _5056_/X sky130_fd_sc_hd__o31a_2
XFILLER_55_18 VGND VGND VPWR VPWR sky130_fd_sc_hd__decap_3
XFILLER_72_407 VGND VGND VPWR VPWR sky130_fd_sc_hd__decap_3
XFILLER_25_334 VGND VGND VPWR VPWR sky130_fd_sc_hd__fill_2
XFILLER_37_161 VGND VGND VPWR VPWR sky130_fd_sc_hd__decap_3
XFILLER_37_172 VGND VGND VPWR VPWR sky130_fd_sc_hd__decap_3
XFILLER_53_610 VGND VGND VPWR VPWR sky130_fd_sc_hd__decap_3
XFILLER_53_632 VGND VGND VPWR VPWR sky130_fd_sc_hd__decap_3
XFILLER_65_481 VGND VGND VPWR VPWR sky130_fd_sc_hd__decap_3
XFILLER_111_46 VGND VGND VPWR VPWR sky130_fd_sc_hd__decap_3
XFILLER_25_367 VGND VGND VPWR VPWR sky130_fd_sc_hd__decap_3
XFILLER_52_153 VGND VGND VPWR VPWR sky130_fd_sc_hd__decap_3
XFILLER_53_676 VGND VGND VPWR VPWR sky130_fd_sc_hd__decap_3
XTAP_TAPCELL_ROW_84_1257 VGND VPWR sky130_fd_sc_hd__tapvpwrvgnd_1
XFILLER_111_57 VGND VGND VPWR VPWR sky130_fd_sc_hd__decap_3
XFILLER_40_304 VGND VGND VPWR VPWR sky130_fd_sc_hd__decap_3
XFILLER_40_315 VGND VGND VPWR VPWR sky130_fd_sc_hd__decap_3
XFILLER_52_186 VGND VGND VPWR VPWR sky130_fd_sc_hd__decap_3
XFILLER_71_28 VGND VGND VPWR VPWR sky130_fd_sc_hd__decap_3
XFILLER_80_495 VGND VGND VPWR VPWR sky130_fd_sc_hd__fill_2
XFILLER_52_197 VGND VGND VPWR VPWR sky130_fd_sc_hd__decap_3
X_4909_ _4909_/A _4909_/B _4909_/C VGND VGND VPWR VPWR _4910_/B sky130_fd_sc_hd__or3_2
XTAP_TAPCELL_ROW_23_524 VGND VPWR sky130_fd_sc_hd__tapvpwrvgnd_1
XTAP_TAPCELL_ROW_51_866 VGND VPWR sky130_fd_sc_hd__tapvpwrvgnd_1
XFILLER_107_601 VGND VGND VPWR VPWR sky130_fd_sc_hd__decap_3
XFILLER_106_100 VGND VGND VPWR VPWR sky130_fd_sc_hd__decap_3
XFILLER_107_656 VGND VGND VPWR VPWR sky130_fd_sc_hd__decap_3
XFILLER_20_21 VGND VGND VPWR VPWR sky130_fd_sc_hd__fill_2
XFILLER_20_32 VGND VGND VPWR VPWR sky130_fd_sc_hd__decap_3
XFILLER_4_249 VGND VGND VPWR VPWR sky130_fd_sc_hd__decap_3
XFILLER_106_166 VGND VGND VPWR VPWR sky130_fd_sc_hd__decap_3
XFILLER_20_65 VGND VGND VPWR VPWR sky130_fd_sc_hd__decap_3
XFILLER_20_76 VGND VGND VPWR VPWR sky130_fd_sc_hd__decap_3
XTAP_TAPCELL_ROW_95_1397 VGND VPWR sky130_fd_sc_hd__tapvpwrvgnd_1
XTAP_TAPCELL_ROW_95_1386 VGND VPWR sky130_fd_sc_hd__tapvpwrvgnd_1
XFILLER_106_188 VGND VGND VPWR VPWR sky130_fd_sc_hd__decap_3
XFILLER_96_14 VGND VGND VPWR VPWR sky130_fd_sc_hd__decap_3
XFILLER_0_433 VGND VGND VPWR VPWR sky130_fd_sc_hd__decap_3
XFILLER_0_455 VGND VGND VPWR VPWR sky130_fd_sc_hd__decap_3
XFILLER_96_47 VGND VGND VPWR VPWR sky130_fd_sc_hd__decap_3
XFILLER_29_30 VGND VGND VPWR VPWR sky130_fd_sc_hd__decap_3
XFILLER_75_212 VGND VGND VPWR VPWR sky130_fd_sc_hd__decap_3
XFILLER_88_595 VGND VGND VPWR VPWR sky130_fd_sc_hd__decap_3
XFILLER_102_383 VGND VGND VPWR VPWR sky130_fd_sc_hd__decap_3
XFILLER_29_63 VGND VGND VPWR VPWR sky130_fd_sc_hd__decap_3
XFILLER_48_437 VGND VGND VPWR VPWR sky130_fd_sc_hd__decap_3
XFILLER_48_448 VGND VGND VPWR VPWR sky130_fd_sc_hd__fill_1
XTAP_TAPCELL_ROW_59_955 VGND VPWR sky130_fd_sc_hd__tapvpwrvgnd_1
XFILLER_28_150 VGND VGND VPWR VPWR sky130_fd_sc_hd__decap_3
XFILLER_28_183 VGND VGND VPWR VPWR sky130_fd_sc_hd__decap_3
XFILLER_44_621 VGND VGND VPWR VPWR sky130_fd_sc_hd__decap_3
Xplace407 _3383_/Y VGND VGND VPWR VPWR _4532_/S sky130_fd_sc_hd__buf_2
Xplace418 _3949_/S VGND VGND VPWR VPWR _3945_/S sky130_fd_sc_hd__buf_2
Xplace429 _4159_/A2 VGND VGND VPWR VPWR _3958_/S sky130_fd_sc_hd__buf_2
XTAP_TAPCELL_ROW_3_293 VGND VPWR sky130_fd_sc_hd__tapvpwrvgnd_1
XTAP_TAPCELL_ROW_3_282 VGND VPWR sky130_fd_sc_hd__tapvpwrvgnd_1
XFILLER_44_654 VGND VGND VPWR VPWR sky130_fd_sc_hd__decap_3
XFILLER_45_51 VGND VGND VPWR VPWR sky130_fd_sc_hd__decap_3
XFILLER_90_259 VGND VGND VPWR VPWR sky130_fd_sc_hd__fill_2
XFILLER_43_153 VGND VGND VPWR VPWR sky130_fd_sc_hd__decap_3
XFILLER_44_687 VGND VGND VPWR VPWR sky130_fd_sc_hd__decap_3
XFILLER_45_84 VGND VGND VPWR VPWR sky130_fd_sc_hd__decap_3
XFILLER_71_495 VGND VGND VPWR VPWR sky130_fd_sc_hd__decap_3
XFILLER_31_359 VGND VGND VPWR VPWR sky130_fd_sc_hd__fill_2
XFILLER_84_9 VGND VGND VPWR VPWR sky130_fd_sc_hd__decap_3
XFILLER_61_72 VGND VGND VPWR VPWR sky130_fd_sc_hd__decap_3
XFILLER_8_533 VGND VGND VPWR VPWR sky130_fd_sc_hd__decap_3
XFILLER_6_12 VGND VGND VPWR VPWR sky130_fd_sc_hd__decap_3
XANTENNA_5 _3896_/Y VGND VGND VPWR VPWR sky130_fd_sc_hd__diode_2
XFILLER_6_56 VGND VGND VPWR VPWR sky130_fd_sc_hd__decap_3
XFILLER_113_615 VGND VGND VPWR VPWR sky130_fd_sc_hd__fill_1
XFILLER_112_103 VGND VGND VPWR VPWR sky130_fd_sc_hd__decap_3
XFILLER_113_626 VGND VGND VPWR VPWR sky130_fd_sc_hd__decap_3
XFILLER_98_348 VGND VGND VPWR VPWR sky130_fd_sc_hd__decap_3
XFILLER_112_136 VGND VGND VPWR VPWR sky130_fd_sc_hd__decap_3
XFILLER_112_147 VGND VGND VPWR VPWR sky130_fd_sc_hd__decap_3
XFILLER_113_659 VGND VGND VPWR VPWR sky130_fd_sc_hd__decap_3
XFILLER_3_293 VGND VGND VPWR VPWR sky130_fd_sc_hd__fill_1
XFILLER_100_309 VGND VGND VPWR VPWR sky130_fd_sc_hd__decap_3
XFILLER_86_91 VGND VGND VPWR VPWR sky130_fd_sc_hd__decap_3
XFILLER_94_554 VGND VGND VPWR VPWR sky130_fd_sc_hd__decap_3
XFILLER_19_150 VGND VGND VPWR VPWR sky130_fd_sc_hd__decap_3
XFILLER_66_256 VGND VGND VPWR VPWR sky130_fd_sc_hd__decap_3
XFILLER_94_587 VGND VGND VPWR VPWR sky130_fd_sc_hd__fill_1
XFILLER_19_172 VGND VGND VPWR VPWR sky130_fd_sc_hd__decap_3
XFILLER_47_470 VGND VGND VPWR VPWR sky130_fd_sc_hd__decap_3
XFILLER_54_429 VGND VGND VPWR VPWR sky130_fd_sc_hd__decap_3
XFILLER_81_237 VGND VGND VPWR VPWR sky130_fd_sc_hd__decap_3
X_6930_ _6975_/CLK _6930_/D VGND VGND VPWR VPWR _6930_/Q sky130_fd_sc_hd__dfxtp_2
XFILLER_81_259 VGND VGND VPWR VPWR sky130_fd_sc_hd__decap_3
X_6861_ _6978_/CLK _6861_/D VGND VGND VPWR VPWR _6861_/Q sky130_fd_sc_hd__dfxtp_2
XFILLER_34_153 VGND VGND VPWR VPWR sky130_fd_sc_hd__decap_3
XFILLER_50_624 VGND VGND VPWR VPWR sky130_fd_sc_hd__decap_3
X_6792_ _6959_/CLK _6792_/D VGND VGND VPWR VPWR _6792_/Q sky130_fd_sc_hd__dfxtp_2
XFILLER_22_359 VGND VGND VPWR VPWR sky130_fd_sc_hd__decap_3
XFILLER_34_186 VGND VGND VPWR VPWR sky130_fd_sc_hd__decap_3
XFILLER_34_197 VGND VGND VPWR VPWR sky130_fd_sc_hd__decap_3
XFILLER_50_657 VGND VGND VPWR VPWR sky130_fd_sc_hd__decap_3
X_5674_ _7343_/Q hold910/X _5719_/S VGND VGND VPWR VPWR _5674_/X sky130_fd_sc_hd__mux2_2
X_4625_ _5099_/A _4625_/A2 _4624_/B _4624_/X VGND VGND VPWR VPWR _4916_/A sky130_fd_sc_hd__a31oi_4
X_7344_ _7386_/CLK _7344_/D _6624_/Y VGND VGND VPWR VPWR _7344_/Q sky130_fd_sc_hd__dfrtp_2
X_4556_ _4556_/A _4561_/B VGND VGND VPWR VPWR _7302_/D sky130_fd_sc_hd__and2_2
XFILLER_116_464 VGND VGND VPWR VPWR sky130_fd_sc_hd__decap_3
X_3507_ _3458_/Y _3505_/X _3506_/Y VGND VGND VPWR VPWR _3508_/B sky130_fd_sc_hd__o21a_2
XFILLER_104_648 VGND VGND VPWR VPWR sky130_fd_sc_hd__decap_3
XFILLER_116_486 VGND VGND VPWR VPWR sky130_fd_sc_hd__decap_3
XFILLER_89_315 VGND VGND VPWR VPWR sky130_fd_sc_hd__decap_3
X_7275_ _7372_/CLK _7275_/D _6555_/Y VGND VGND VPWR VPWR _7275_/Q sky130_fd_sc_hd__dfrtp_2
Xhold588 _6786_/Q VGND VGND VPWR VPWR _6786_/D sky130_fd_sc_hd__dlygate4sd3_1
XFILLER_106_24 VGND VGND VPWR VPWR sky130_fd_sc_hd__decap_3
XFILLER_106_35 VGND VGND VPWR VPWR sky130_fd_sc_hd__decap_3
Xhold599 _6746_/Q VGND VGND VPWR VPWR _6746_/D sky130_fd_sc_hd__dlygate4sd3_1
X_3438_ _7314_/Q _3973_/S _4338_/B1 _7346_/Q _3556_/A VGND VGND VPWR VPWR _3438_/X
+ sky130_fd_sc_hd__a221o_2
XFILLER_103_169 VGND VGND VPWR VPWR sky130_fd_sc_hd__decap_3
XFILLER_106_68 VGND VGND VPWR VPWR sky130_fd_sc_hd__decap_3
XFILLER_112_681 VGND VGND VPWR VPWR sky130_fd_sc_hd__decap_3
XFILLER_97_370 VGND VGND VPWR VPWR sky130_fd_sc_hd__decap_3
Xhold1200 _7330_/Q VGND VGND VPWR VPWR _4499_/A0 sky130_fd_sc_hd__dlygate4sd3_1
X_3369_ _3369_/A _5668_/A VGND VGND VPWR VPWR _3560_/B sky130_fd_sc_hd__nand2_2
XFILLER_111_191 VGND VGND VPWR VPWR sky130_fd_sc_hd__decap_3
XFILLER_57_223 VGND VGND VPWR VPWR sky130_fd_sc_hd__fill_1
XFILLER_57_245 VGND VGND VPWR VPWR sky130_fd_sc_hd__decap_3
Xhold1211 _7296_/Q VGND VGND VPWR VPWR _4569_/A sky130_fd_sc_hd__dlygate4sd3_1
X_5108_ _5108_/A0 _5107_/X _5159_/S VGND VGND VPWR VPWR _7255_/D sky130_fd_sc_hd__mux2_2
XFILLER_26_610 VGND VGND VPWR VPWR sky130_fd_sc_hd__decap_3
XFILLER_38_470 VGND VGND VPWR VPWR sky130_fd_sc_hd__decap_3
XFILLER_38_492 VGND VGND VPWR VPWR sky130_fd_sc_hd__decap_3
XFILLER_72_226 VGND VGND VPWR VPWR sky130_fd_sc_hd__decap_3
X_5039_ _4677_/B _3856_/X _5658_/B _5038_/X _4960_/A VGND VGND VPWR VPWR _5039_/X
+ sky130_fd_sc_hd__o32a_2
XTAP_TAPCELL_ROW_56_925 VGND VPWR sky130_fd_sc_hd__tapvpwrvgnd_1
XFILLER_25_120 VGND VGND VPWR VPWR sky130_fd_sc_hd__decap_3
XFILLER_82_38 VGND VGND VPWR VPWR sky130_fd_sc_hd__decap_3
XTAP_TAPCELL_ROW_0_252 VGND VPWR sky130_fd_sc_hd__tapvpwrvgnd_1
XTAP_TAPCELL_ROW_0_241 VGND VPWR sky130_fd_sc_hd__tapvpwrvgnd_1
XFILLER_15_21 VGND VGND VPWR VPWR sky130_fd_sc_hd__decap_3
XFILLER_25_175 VGND VGND VPWR VPWR sky130_fd_sc_hd__decap_3
XFILLER_13_337 VGND VGND VPWR VPWR sky130_fd_sc_hd__decap_3
XFILLER_15_54 VGND VGND VPWR VPWR sky130_fd_sc_hd__fill_2
XFILLER_25_197 VGND VGND VPWR VPWR sky130_fd_sc_hd__decap_3
XFILLER_40_112 VGND VGND VPWR VPWR sky130_fd_sc_hd__fill_1
XFILLER_40_123 VGND VGND VPWR VPWR sky130_fd_sc_hd__decap_3
XFILLER_41_635 VGND VGND VPWR VPWR sky130_fd_sc_hd__fill_1
XTAP_TAPCELL_ROW_36_682 VGND VPWR sky130_fd_sc_hd__tapvpwrvgnd_1
XFILLER_15_87 VGND VGND VPWR VPWR sky130_fd_sc_hd__fill_1
XFILLER_41_668 VGND VGND VPWR VPWR sky130_fd_sc_hd__decap_3
XFILLER_41_679 VGND VGND VPWR VPWR sky130_fd_sc_hd__decap_3
XFILLER_21_370 VGND VGND VPWR VPWR sky130_fd_sc_hd__decap_3
XFILLER_40_189 VGND VGND VPWR VPWR sky130_fd_sc_hd__decap_3
XTAP_TAPCELL_ROW_97_1415 VGND VPWR sky130_fd_sc_hd__tapvpwrvgnd_1
XFILLER_5_503 VGND VGND VPWR VPWR sky130_fd_sc_hd__fill_1
XFILLER_31_86 VGND VGND VPWR VPWR sky130_fd_sc_hd__decap_3
XFILLER_107_464 VGND VGND VPWR VPWR sky130_fd_sc_hd__fill_1
XFILLER_107_486 VGND VGND VPWR VPWR sky130_fd_sc_hd__decap_3
XFILLER_110_607 VGND VGND VPWR VPWR sky130_fd_sc_hd__decap_3
XTAP_TAPCELL_ROW_8_352 VGND VPWR sky130_fd_sc_hd__tapvpwrvgnd_1
XFILLER_0_274 VGND VGND VPWR VPWR sky130_fd_sc_hd__decap_3
XFILLER_48_234 VGND VGND VPWR VPWR sky130_fd_sc_hd__fill_1
XFILLER_88_381 VGND VGND VPWR VPWR sky130_fd_sc_hd__decap_3
XFILLER_102_191 VGND VGND VPWR VPWR sky130_fd_sc_hd__decap_3
XFILLER_76_554 VGND VGND VPWR VPWR sky130_fd_sc_hd__decap_3
XFILLER_48_289 VGND VGND VPWR VPWR sky130_fd_sc_hd__fill_1
XFILLER_56_83 VGND VGND VPWR VPWR sky130_fd_sc_hd__fill_1
XFILLER_63_215 VGND VGND VPWR VPWR sky130_fd_sc_hd__fill_2
XFILLER_91_546 VGND VGND VPWR VPWR sky130_fd_sc_hd__decap_3
XFILLER_17_643 VGND VGND VPWR VPWR sky130_fd_sc_hd__decap_3
XTAP_TAPCELL_ROW_106_1522 VGND VPWR sky130_fd_sc_hd__tapvpwrvgnd_1
XFILLER_16_153 VGND VGND VPWR VPWR sky130_fd_sc_hd__decap_3
XFILLER_32_624 VGND VGND VPWR VPWR sky130_fd_sc_hd__decap_3
XFILLER_16_197 VGND VGND VPWR VPWR sky130_fd_sc_hd__decap_3
XFILLER_71_281 VGND VGND VPWR VPWR sky130_fd_sc_hd__decap_3
XFILLER_31_167 VGND VGND VPWR VPWR sky130_fd_sc_hd__fill_1
XFILLER_72_93 VGND VGND VPWR VPWR sky130_fd_sc_hd__decap_3
XFILLER_31_178 VGND VGND VPWR VPWR sky130_fd_sc_hd__decap_3
XFILLER_82_6 VGND VGND VPWR VPWR sky130_fd_sc_hd__decap_3
XFILLER_8_385 VGND VGND VPWR VPWR sky130_fd_sc_hd__decap_3
X_4410_ _4411_/A _4411_/B VGND VGND VPWR VPWR _4788_/B sky130_fd_sc_hd__nor2_2
X_5390_ _5390_/A0 _4932_/X _5396_/S VGND VGND VPWR VPWR _7138_/D sky130_fd_sc_hd__mux2_2
XFILLER_113_401 VGND VGND VPWR VPWR sky130_fd_sc_hd__decap_3
X_4341_ _7255_/Q _4601_/S wire566/X _7127_/Q _4340_/X VGND VGND VPWR VPWR _4365_/A
+ sky130_fd_sc_hd__a221o_2
XFILLER_113_434 VGND VGND VPWR VPWR sky130_fd_sc_hd__decap_3
X_7060_ clkload8/A _7060_/D _6340_/Y VGND VGND VPWR VPWR _7060_/Q sky130_fd_sc_hd__dfrtp_2
X_4272_ _4394_/A _4272_/B _4271_/X VGND VGND VPWR VPWR _4273_/D sky130_fd_sc_hd__or3b_2
XFILLER_99_679 VGND VGND VPWR VPWR sky130_fd_sc_hd__decap_3
XFILLER_99_668 VGND VGND VPWR VPWR sky130_fd_sc_hd__decap_3
XFILLER_98_156 VGND VGND VPWR VPWR sky130_fd_sc_hd__decap_3
XFILLER_98_123 VGND VGND VPWR VPWR sky130_fd_sc_hd__decap_3
XFILLER_113_467 VGND VGND VPWR VPWR sky130_fd_sc_hd__decap_3
XFILLER_100_139 VGND VGND VPWR VPWR sky130_fd_sc_hd__fill_1
XFILLER_39_212 VGND VGND VPWR VPWR sky130_fd_sc_hd__decap_3
XFILLER_39_234 VGND VGND VPWR VPWR sky130_fd_sc_hd__decap_3
XFILLER_94_362 VGND VGND VPWR VPWR sky130_fd_sc_hd__fill_2
XFILLER_67_598 VGND VGND VPWR VPWR sky130_fd_sc_hd__decap_3
XFILLER_94_373 VGND VGND VPWR VPWR sky130_fd_sc_hd__decap_3
XFILLER_82_557 VGND VGND VPWR VPWR sky130_fd_sc_hd__decap_3
X_6913_ _6931_/CLK _6913_/D VGND VGND VPWR VPWR _6913_/Q sky130_fd_sc_hd__dfxtp_2
XFILLER_23_613 VGND VGND VPWR VPWR sky130_fd_sc_hd__decap_3
XFILLER_22_112 VGND VGND VPWR VPWR sky130_fd_sc_hd__decap_3
XFILLER_50_421 VGND VGND VPWR VPWR sky130_fd_sc_hd__fill_1
X_6844_ _6929_/CLK _6844_/D VGND VGND VPWR VPWR _6844_/Q sky130_fd_sc_hd__dfxtp_2
XTAP_TAPCELL_ROW_81_1227 VGND VPWR sky130_fd_sc_hd__tapvpwrvgnd_1
X_6775_ _6976_/CLK _6775_/D VGND VGND VPWR VPWR _6775_/Q sky130_fd_sc_hd__dfxtp_2
X_3987_ _7347_/Q _4528_/A _3989_/S VGND VGND VPWR VPWR _7347_/D sky130_fd_sc_hd__mux2_2
XTAP_TAPCELL_ROW_33_652 VGND VPWR sky130_fd_sc_hd__tapvpwrvgnd_1
XFILLER_22_178 VGND VGND VPWR VPWR sky130_fd_sc_hd__decap_3
XTAP_TAPCELL_ROW_61_983 VGND VPWR sky130_fd_sc_hd__tapvpwrvgnd_1
XFILLER_108_217 VGND VGND VPWR VPWR sky130_fd_sc_hd__decap_3
X_5657_ _5657_/A _5657_/B _5657_/C _5657_/D VGND VGND VPWR VPWR _5664_/C sky130_fd_sc_hd__nor4_2
X_4608_ _4938_/A _4608_/B VGND VGND VPWR VPWR _4608_/Y sky130_fd_sc_hd__nor2_2
XFILLER_116_261 VGND VGND VPWR VPWR sky130_fd_sc_hd__decap_3
X_7327_ _7397_/CLK _7327_/D _6607_/Y VGND VGND VPWR VPWR _7327_/Q sky130_fd_sc_hd__dfrtp_2
XFILLER_77_27 VGND VGND VPWR VPWR sky130_fd_sc_hd__decap_3
XFILLER_89_134 VGND VGND VPWR VPWR sky130_fd_sc_hd__decap_3
X_7258_ _7279_/CLK _7258_/D _6538_/Y VGND VGND VPWR VPWR _7258_/Q sky130_fd_sc_hd__dfrtp_2
XTAP_TAPCELL_ROW_92_1356 VGND VPWR sky130_fd_sc_hd__tapvpwrvgnd_1
XFILLER_77_329 VGND VGND VPWR VPWR sky130_fd_sc_hd__decap_3
XFILLER_89_156 VGND VGND VPWR VPWR sky130_fd_sc_hd__decap_3
XTAP_TAPCELL_ROW_5_311 VGND VPWR sky130_fd_sc_hd__tapvpwrvgnd_1
X_7189_ clkload9/A _7189_/D _6469_/Y VGND VGND VPWR VPWR _7189_/Q sky130_fd_sc_hd__dfrtp_2
XFILLER_100_651 VGND VGND VPWR VPWR sky130_fd_sc_hd__decap_3
XFILLER_93_15 VGND VGND VPWR VPWR sky130_fd_sc_hd__decap_3
Xhold1030 _7258_/Q VGND VGND VPWR VPWR _5063_/A0 sky130_fd_sc_hd__dlygate4sd3_1
Xhold1041 _7260_/Q VGND VGND VPWR VPWR _5028_/A0 sky130_fd_sc_hd__dlygate4sd3_1
XFILLER_100_684 VGND VGND VPWR VPWR sky130_fd_sc_hd__decap_3
XFILLER_58_587 VGND VGND VPWR VPWR sky130_fd_sc_hd__fill_1
XFILLER_93_48 VGND VGND VPWR VPWR sky130_fd_sc_hd__decap_3
Xhold1052 _7198_/Q VGND VGND VPWR VPWR _5264_/A0 sky130_fd_sc_hd__dlygate4sd3_1
Xhold1063 _7261_/Q VGND VGND VPWR VPWR _5012_/A0 sky130_fd_sc_hd__dlygate4sd3_1
Xhold1074 _7048_/Q VGND VGND VPWR VPWR _5569_/A1 sky130_fd_sc_hd__dlygate4sd3_1
Xhold1085 _7238_/Q VGND VGND VPWR VPWR _5179_/A sky130_fd_sc_hd__dlygate4sd3_1
XFILLER_45_237 VGND VGND VPWR VPWR sky130_fd_sc_hd__decap_3
XFILLER_73_557 VGND VGND VPWR VPWR sky130_fd_sc_hd__decap_3
Xhold1096 _7249_/Q VGND VGND VPWR VPWR _5142_/A0 sky130_fd_sc_hd__dlygate4sd3_1
XFILLER_26_451 VGND VGND VPWR VPWR sky130_fd_sc_hd__fill_2
XFILLER_26_64 VGND VGND VPWR VPWR sky130_fd_sc_hd__decap_3
XFILLER_60_218 VGND VGND VPWR VPWR sky130_fd_sc_hd__decap_3
Xclkbuf_3_6__f_clk clkbuf_0_clk/X VGND VGND VPWR VPWR clkbuf_3_6__f_clk/X sky130_fd_sc_hd__clkbuf_16
XFILLER_26_97 VGND VGND VPWR VPWR sky130_fd_sc_hd__decap_3
XFILLER_53_270 VGND VGND VPWR VPWR sky130_fd_sc_hd__decap_3
XFILLER_53_281 VGND VGND VPWR VPWR sky130_fd_sc_hd__decap_3
XFILLER_13_134 VGND VGND VPWR VPWR sky130_fd_sc_hd__decap_3
XFILLER_13_156 VGND VGND VPWR VPWR sky130_fd_sc_hd__decap_3
XFILLER_13_178 VGND VGND VPWR VPWR sky130_fd_sc_hd__decap_3
XFILLER_41_498 VGND VGND VPWR VPWR sky130_fd_sc_hd__decap_3
XFILLER_42_52 VGND VGND VPWR VPWR sky130_fd_sc_hd__decap_3
XTAP_TAPCELL_ROW_101_1463 VGND VPWR sky130_fd_sc_hd__tapvpwrvgnd_1
XFILLER_9_127 VGND VGND VPWR VPWR sky130_fd_sc_hd__decap_3
XFILLER_42_74 VGND VGND VPWR VPWR sky130_fd_sc_hd__decap_3
XFILLER_42_85 VGND VGND VPWR VPWR sky130_fd_sc_hd__fill_2
XFILLER_5_311 VGND VGND VPWR VPWR sky130_fd_sc_hd__decap_3
XTAP_TAPCELL_ROW_11_379 VGND VPWR sky130_fd_sc_hd__tapvpwrvgnd_1
XFILLER_114_209 VGND VGND VPWR VPWR sky130_fd_sc_hd__decap_3
XFILLER_5_333 VGND VGND VPWR VPWR sky130_fd_sc_hd__decap_3
XFILLER_5_377 VGND VGND VPWR VPWR sky130_fd_sc_hd__fill_1
XFILLER_47_9 VGND VGND VPWR VPWR sky130_fd_sc_hd__fill_1
XFILLER_3_24 VGND VGND VPWR VPWR sky130_fd_sc_hd__decap_3
XFILLER_68_307 VGND VGND VPWR VPWR sky130_fd_sc_hd__fill_1
XFILLER_3_57 VGND VGND VPWR VPWR sky130_fd_sc_hd__decap_3
XFILLER_95_126 VGND VGND VPWR VPWR sky130_fd_sc_hd__fill_2
XTAP_TAPCELL_ROW_112_1592 VGND VPWR sky130_fd_sc_hd__tapvpwrvgnd_1
XFILLER_95_159 VGND VGND VPWR VPWR sky130_fd_sc_hd__decap_3
XFILLER_76_373 VGND VGND VPWR VPWR sky130_fd_sc_hd__decap_3
XFILLER_36_237 VGND VGND VPWR VPWR sky130_fd_sc_hd__fill_2
XFILLER_36_259 VGND VGND VPWR VPWR sky130_fd_sc_hd__decap_3
XFILLER_51_218 VGND VGND VPWR VPWR sky130_fd_sc_hd__decap_3
XTAP_TAPCELL_ROW_67_1060 VGND VPWR sky130_fd_sc_hd__tapvpwrvgnd_1
XTAP_TAPCELL_ROW_19_479 VGND VPWR sky130_fd_sc_hd__tapvpwrvgnd_1
XFILLER_32_410 VGND VGND VPWR VPWR sky130_fd_sc_hd__decap_3
XFILLER_32_421 VGND VGND VPWR VPWR sky130_fd_sc_hd__decap_3
XFILLER_32_432 VGND VGND VPWR VPWR sky130_fd_sc_hd__decap_3
XFILLER_44_281 VGND VGND VPWR VPWR sky130_fd_sc_hd__decap_3
XFILLER_83_92 VGND VGND VPWR VPWR sky130_fd_sc_hd__decap_3
X_4890_ _5101_/A _4890_/B VGND VGND VPWR VPWR _4890_/Y sky130_fd_sc_hd__nor2_2
X_3910_ _6916_/Q _3912_/A2 _3913_/A2 _6780_/Q VGND VGND VPWR VPWR _3910_/X sky130_fd_sc_hd__a22o_2
X_3841_ _6845_/Q _3886_/A2 _3853_/B1 _6830_/Q _3840_/X VGND VGND VPWR VPWR _3841_/X
+ sky130_fd_sc_hd__a221o_2
X_6560_ _6634_/A VGND VGND VPWR VPWR _6560_/Y sky130_fd_sc_hd__inv_2
X_3772_ _6854_/Q _3889_/B1 _3912_/B1 _6902_/Q _3771_/X VGND VGND VPWR VPWR _3772_/X
+ sky130_fd_sc_hd__a221o_2
XTAP_TAPCELL_ROW_30_611 VGND VPWR sky130_fd_sc_hd__tapvpwrvgnd_1
XFILLER_9_661 VGND VGND VPWR VPWR sky130_fd_sc_hd__decap_3
X_6491_ _6578_/A VGND VGND VPWR VPWR _6491_/Y sky130_fd_sc_hd__inv_2
X_5373_ _5373_/A0 _4792_/X _5383_/S VGND VGND VPWR VPWR _7146_/D sky130_fd_sc_hd__mux2_2
XFILLER_99_410 VGND VGND VPWR VPWR sky130_fd_sc_hd__decap_3
XFILLER_113_220 VGND VGND VPWR VPWR sky130_fd_sc_hd__decap_3
XFILLER_113_231 VGND VGND VPWR VPWR sky130_fd_sc_hd__decap_3
X_7112_ _7363_/CLK _7112_/D _6392_/Y VGND VGND VPWR VPWR _7112_/Q sky130_fd_sc_hd__dfrtp_2
Xoutput468 _4973_/B VGND VGND VPWR VPWR alu_result_out[16] sky130_fd_sc_hd__clkdlybuf4s25_1
X_4324_ _7039_/Q _4503_/S _4354_/B1 _7386_/Q VGND VGND VPWR VPWR _4324_/X sky130_fd_sc_hd__a22o_2
X_7043_ _7230_/CLK _7043_/D _6323_/Y VGND VGND VPWR VPWR _7043_/Q sky130_fd_sc_hd__dfrtp_2
Xoutput479 _5656_/A VGND VGND VPWR VPWR alu_result_out[26] sky130_fd_sc_hd__clkdlybuf4s25_1
XFILLER_99_465 VGND VGND VPWR VPWR sky130_fd_sc_hd__decap_3
XFILLER_101_426 VGND VGND VPWR VPWR sky130_fd_sc_hd__decap_3
X_4255_ _4251_/X _4254_/X _4327_/A VGND VGND VPWR VPWR _4256_/C sky130_fd_sc_hd__o21ai_2
XFILLER_86_159 VGND VGND VPWR VPWR sky130_fd_sc_hd__decap_3
X_4186_ _4186_/A _4636_/B VGND VGND VPWR VPWR _4186_/Y sky130_fd_sc_hd__xnor2_2
XFILLER_27_215 VGND VGND VPWR VPWR sky130_fd_sc_hd__decap_3
XFILLER_94_170 VGND VGND VPWR VPWR sky130_fd_sc_hd__decap_3
XFILLER_95_671 VGND VGND VPWR VPWR sky130_fd_sc_hd__fill_1
XFILLER_95_682 VGND VGND VPWR VPWR sky130_fd_sc_hd__decap_3
XTAP_TAPCELL_ROW_38_711 VGND VPWR sky130_fd_sc_hd__tapvpwrvgnd_1
XFILLER_103_36 VGND VGND VPWR VPWR sky130_fd_sc_hd__decap_3
XFILLER_27_237 VGND VGND VPWR VPWR sky130_fd_sc_hd__decap_3
XFILLER_82_321 VGND VGND VPWR VPWR sky130_fd_sc_hd__decap_3
XFILLER_82_354 VGND VGND VPWR VPWR sky130_fd_sc_hd__decap_3
XFILLER_103_69 VGND VGND VPWR VPWR sky130_fd_sc_hd__decap_3
XFILLER_63_18 VGND VGND VPWR VPWR sky130_fd_sc_hd__decap_3
XFILLER_70_516 VGND VGND VPWR VPWR sky130_fd_sc_hd__decap_3
XFILLER_82_365 VGND VGND VPWR VPWR sky130_fd_sc_hd__decap_3
XFILLER_23_421 VGND VGND VPWR VPWR sky130_fd_sc_hd__decap_3
XFILLER_35_281 VGND VGND VPWR VPWR sky130_fd_sc_hd__fill_2
XFILLER_82_398 VGND VGND VPWR VPWR sky130_fd_sc_hd__decap_3
XFILLER_11_605 VGND VGND VPWR VPWR sky130_fd_sc_hd__fill_1
X_6827_ _6972_/CLK _6827_/D VGND VGND VPWR VPWR _6827_/Q sky130_fd_sc_hd__dfxtp_2
XFILLER_10_126 VGND VGND VPWR VPWR sky130_fd_sc_hd__decap_3
X_6758_ _6959_/CLK _6758_/D VGND VGND VPWR VPWR _6758_/Q sky130_fd_sc_hd__dfxtp_2
XFILLER_109_548 VGND VGND VPWR VPWR sky130_fd_sc_hd__decap_3
XFILLER_12_44 VGND VGND VPWR VPWR sky130_fd_sc_hd__decap_3
X_6689_ _7384_/CLK _6689_/D VGND VGND VPWR VPWR _6689_/Q sky130_fd_sc_hd__dfxtp_2
XFILLER_104_253 VGND VGND VPWR VPWR sky130_fd_sc_hd__decap_3
XFILLER_77_104 VGND VGND VPWR VPWR sky130_fd_sc_hd__decap_3
XFILLER_100_470 VGND VGND VPWR VPWR sky130_fd_sc_hd__decap_3
XFILLER_58_362 VGND VGND VPWR VPWR sky130_fd_sc_hd__fill_2
XFILLER_86_671 VGND VGND VPWR VPWR sky130_fd_sc_hd__decap_3
XFILLER_92_129 VGND VGND VPWR VPWR sky130_fd_sc_hd__decap_3
XFILLER_100_492 VGND VGND VPWR VPWR sky130_fd_sc_hd__decap_3
XFILLER_18_248 VGND VGND VPWR VPWR sky130_fd_sc_hd__decap_3
XFILLER_37_63 VGND VGND VPWR VPWR sky130_fd_sc_hd__decap_3
XFILLER_73_321 VGND VGND VPWR VPWR sky130_fd_sc_hd__decap_3
XFILLER_37_96 VGND VGND VPWR VPWR sky130_fd_sc_hd__decap_3
XFILLER_61_505 VGND VGND VPWR VPWR sky130_fd_sc_hd__decap_3
XTAP_TAPCELL_ROW_16_438 VGND VPWR sky130_fd_sc_hd__tapvpwrvgnd_1
XFILLER_26_292 VGND VGND VPWR VPWR sky130_fd_sc_hd__decap_3
XFILLER_41_240 VGND VGND VPWR VPWR sky130_fd_sc_hd__decap_3
XFILLER_53_51 VGND VGND VPWR VPWR sky130_fd_sc_hd__decap_3
XTAP_TAPCELL_ROW_16_449 VGND VPWR sky130_fd_sc_hd__tapvpwrvgnd_1
XFILLER_41_273 VGND VGND VPWR VPWR sky130_fd_sc_hd__decap_3
XFILLER_41_284 VGND VGND VPWR VPWR sky130_fd_sc_hd__decap_3
XFILLER_10_671 VGND VGND VPWR VPWR sky130_fd_sc_hd__decap_3
XFILLER_6_642 VGND VGND VPWR VPWR sky130_fd_sc_hd__fill_2
XFILLER_5_163 VGND VGND VPWR VPWR sky130_fd_sc_hd__decap_3
XFILLER_6_675 VGND VGND VPWR VPWR sky130_fd_sc_hd__decap_3
XTAP_TAPCELL_ROW_114_1621 VGND VPWR sky130_fd_sc_hd__tapvpwrvgnd_1
XFILLER_108_592 VGND VGND VPWR VPWR sky130_fd_sc_hd__decap_3
XFILLER_69_627 VGND VGND VPWR VPWR sky130_fd_sc_hd__decap_3
XFILLER_110_212 VGND VGND VPWR VPWR sky130_fd_sc_hd__fill_2
XFILLER_78_70 VGND VGND VPWR VPWR sky130_fd_sc_hd__decap_3
XFILLER_96_424 VGND VGND VPWR VPWR sky130_fd_sc_hd__decap_3
XFILLER_110_256 VGND VGND VPWR VPWR sky130_fd_sc_hd__decap_3
XFILLER_84_619 VGND VGND VPWR VPWR sky130_fd_sc_hd__fill_1
X_4040_ _4608_/B _4040_/B VGND VGND VPWR VPWR _4040_/Y sky130_fd_sc_hd__nor2_2
XFILLER_77_671 VGND VGND VPWR VPWR sky130_fd_sc_hd__fill_1
XFILLER_77_682 VGND VGND VPWR VPWR sky130_fd_sc_hd__decap_3
XFILLER_83_107 VGND VGND VPWR VPWR sky130_fd_sc_hd__decap_3
XFILLER_64_321 VGND VGND VPWR VPWR sky130_fd_sc_hd__decap_3
XFILLER_64_343 VGND VGND VPWR VPWR sky130_fd_sc_hd__decap_3
XFILLER_76_181 VGND VGND VPWR VPWR sky130_fd_sc_hd__decap_3
XFILLER_52_516 VGND VGND VPWR VPWR sky130_fd_sc_hd__decap_3
XFILLER_64_365 VGND VGND VPWR VPWR sky130_fd_sc_hd__decap_3
XFILLER_92_663 VGND VGND VPWR VPWR sky130_fd_sc_hd__decap_3
XFILLER_17_270 VGND VGND VPWR VPWR sky130_fd_sc_hd__decap_3
XFILLER_64_387 VGND VGND VPWR VPWR sky130_fd_sc_hd__decap_3
X_4942_ _6995_/Q _4960_/B _4677_/B _3403_/A VGND VGND VPWR VPWR _4943_/B sky130_fd_sc_hd__o211ai_2
XFILLER_17_292 VGND VGND VPWR VPWR sky130_fd_sc_hd__fill_1
XFILLER_20_413 VGND VGND VPWR VPWR sky130_fd_sc_hd__decap_3
XFILLER_32_262 VGND VGND VPWR VPWR sky130_fd_sc_hd__decap_3
X_6612_ _6644_/A VGND VGND VPWR VPWR _6612_/Y sky130_fd_sc_hd__inv_2
X_4873_ _4764_/B _4111_/B _4845_/A _5101_/A VGND VGND VPWR VPWR _4873_/X sky130_fd_sc_hd__o22a_2
X_3824_ _6965_/Q _3884_/A2 _3883_/A2 _6953_/Q _3823_/X VGND VGND VPWR VPWR _3824_/X
+ sky130_fd_sc_hd__a221o_2
X_6543_ _6548_/A VGND VGND VPWR VPWR _6543_/Y sky130_fd_sc_hd__inv_2
X_3755_ _6934_/Q _3902_/A2 _3925_/B1 _6886_/Q VGND VGND VPWR VPWR _3755_/X sky130_fd_sc_hd__a22o_2
X_6474_ _6638_/A VGND VGND VPWR VPWR _6474_/Y sky130_fd_sc_hd__inv_2
X_5425_ _5425_/A0 _3993_/X _5429_/S VGND VGND VPWR VPWR _7121_/D sky130_fd_sc_hd__mux2_2
XPHY_EDGE_ROW_12_Right_12 VGND VGND VPWR VPWR sky130_fd_sc_hd__decap_3
XTAP_TAPCELL_ROW_76_1159 VGND VPWR sky130_fd_sc_hd__tapvpwrvgnd_1
XFILLER_58_29 VGND VGND VPWR VPWR sky130_fd_sc_hd__decap_3
X_5356_ _5356_/A0 _3993_/X _5360_/S VGND VGND VPWR VPWR _7153_/D sky130_fd_sc_hd__mux2_2
XFILLER_99_251 VGND VGND VPWR VPWR sky130_fd_sc_hd__decap_3
XFILLER_101_223 VGND VGND VPWR VPWR sky130_fd_sc_hd__fill_1
XFILLER_114_584 VGND VGND VPWR VPWR sky130_fd_sc_hd__decap_3
XFILLER_114_595 VGND VGND VPWR VPWR sky130_fd_sc_hd__decap_3
XFILLER_59_104 VGND VGND VPWR VPWR sky130_fd_sc_hd__decap_3
XFILLER_59_126 VGND VGND VPWR VPWR sky130_fd_sc_hd__decap_3
XFILLER_87_424 VGND VGND VPWR VPWR sky130_fd_sc_hd__decap_3
X_4307_ _7224_/Q _4331_/A2 _4530_/S _7037_/Q VGND VGND VPWR VPWR _4307_/X sky130_fd_sc_hd__a22o_2
XFILLER_99_284 VGND VGND VPWR VPWR sky130_fd_sc_hd__decap_3
XFILLER_101_234 VGND VGND VPWR VPWR sky130_fd_sc_hd__fill_1
XFILLER_114_24 VGND VGND VPWR VPWR sky130_fd_sc_hd__decap_3
XFILLER_87_468 VGND VGND VPWR VPWR sky130_fd_sc_hd__decap_3
X_7026_ _7374_/CLK _7026_/D _6306_/Y VGND VGND VPWR VPWR _7026_/Q sky130_fd_sc_hd__dfrtp_2
X_4238_ _7067_/Q _4305_/B _4460_/A _4237_/X VGND VGND VPWR VPWR _4629_/B sky130_fd_sc_hd__o211ai_2
XFILLER_101_267 VGND VGND VPWR VPWR sky130_fd_sc_hd__decap_3
XFILLER_114_35 VGND VGND VPWR VPWR sky130_fd_sc_hd__decap_3
XFILLER_114_68 VGND VGND VPWR VPWR sky130_fd_sc_hd__decap_3
XFILLER_28_557 VGND VGND VPWR VPWR sky130_fd_sc_hd__fill_2
XFILLER_55_321 VGND VGND VPWR VPWR sky130_fd_sc_hd__decap_3
XFILLER_55_343 VGND VGND VPWR VPWR sky130_fd_sc_hd__decap_3
XFILLER_67_192 VGND VGND VPWR VPWR sky130_fd_sc_hd__decap_3
XFILLER_74_17 VGND VGND VPWR VPWR sky130_fd_sc_hd__decap_3
XFILLER_83_641 VGND VGND VPWR VPWR sky130_fd_sc_hd__decap_3
X_4169_ _4165_/X _4168_/X _4425_/A VGND VGND VPWR VPWR _4202_/A sky130_fd_sc_hd__o21a_2
XFILLER_55_376 VGND VGND VPWR VPWR sky130_fd_sc_hd__decap_3
XFILLER_83_663 VGND VGND VPWR VPWR sky130_fd_sc_hd__decap_3
XPHY_EDGE_ROW_21_Right_21 VGND VGND VPWR VPWR sky130_fd_sc_hd__decap_3
XFILLER_82_195 VGND VGND VPWR VPWR sky130_fd_sc_hd__fill_1
XTAP_TAPCELL_ROW_87_1299 VGND VPWR sky130_fd_sc_hd__tapvpwrvgnd_1
XFILLER_11_402 VGND VGND VPWR VPWR sky130_fd_sc_hd__decap_3
XFILLER_23_21 VGND VGND VPWR VPWR sky130_fd_sc_hd__decap_3
XFILLER_23_262 VGND VGND VPWR VPWR sky130_fd_sc_hd__decap_3
XTAP_TAPCELL_ROW_41_739 VGND VPWR sky130_fd_sc_hd__tapvpwrvgnd_1
XTAP_TAPCELL_ROW_13_408 VGND VPWR sky130_fd_sc_hd__tapvpwrvgnd_1
XFILLER_23_284 VGND VGND VPWR VPWR sky130_fd_sc_hd__decap_3
XFILLER_109_312 VGND VGND VPWR VPWR sky130_fd_sc_hd__fill_1
XFILLER_109_334 VGND VGND VPWR VPWR sky130_fd_sc_hd__fill_2
XPHY_EDGE_ROW_30_Right_30 VGND VGND VPWR VPWR sky130_fd_sc_hd__decap_3
XFILLER_99_36 VGND VGND VPWR VPWR sky130_fd_sc_hd__decap_3
XFILLER_3_612 VGND VGND VPWR VPWR sky130_fd_sc_hd__decap_3
XFILLER_99_69 VGND VGND VPWR VPWR sky130_fd_sc_hd__decap_3
XFILLER_2_100 VGND VGND VPWR VPWR sky130_fd_sc_hd__decap_3
XFILLER_105_540 VGND VGND VPWR VPWR sky130_fd_sc_hd__decap_3
XFILLER_2_133 VGND VGND VPWR VPWR sky130_fd_sc_hd__decap_3
XFILLER_2_144 VGND VGND VPWR VPWR sky130_fd_sc_hd__decap_3
XFILLER_3_656 VGND VGND VPWR VPWR sky130_fd_sc_hd__decap_3
XFILLER_78_424 VGND VGND VPWR VPWR sky130_fd_sc_hd__decap_3
XFILLER_78_457 VGND VGND VPWR VPWR sky130_fd_sc_hd__decap_3
XFILLER_78_468 VGND VGND VPWR VPWR sky130_fd_sc_hd__decap_3
XFILLER_19_502 VGND VGND VPWR VPWR sky130_fd_sc_hd__fill_2
XFILLER_48_95 VGND VGND VPWR VPWR sky130_fd_sc_hd__fill_2
XFILLER_59_671 VGND VGND VPWR VPWR sky130_fd_sc_hd__fill_1
XFILLER_59_682 VGND VGND VPWR VPWR sky130_fd_sc_hd__decap_3
XFILLER_65_107 VGND VGND VPWR VPWR sky130_fd_sc_hd__decap_3
XFILLER_93_416 VGND VGND VPWR VPWR sky130_fd_sc_hd__decap_3
XTAP_TAPCELL_ROW_49_839 VGND VPWR sky130_fd_sc_hd__tapvpwrvgnd_1
XFILLER_0_14 VGND VGND VPWR VPWR sky130_fd_sc_hd__decap_3
XFILLER_46_332 VGND VGND VPWR VPWR sky130_fd_sc_hd__decap_3
XFILLER_58_192 VGND VGND VPWR VPWR sky130_fd_sc_hd__decap_3
XFILLER_74_641 VGND VGND VPWR VPWR sky130_fd_sc_hd__decap_3
XFILLER_0_47 VGND VGND VPWR VPWR sky130_fd_sc_hd__decap_3
XFILLER_46_354 VGND VGND VPWR VPWR sky130_fd_sc_hd__decap_3
XFILLER_61_302 VGND VGND VPWR VPWR sky130_fd_sc_hd__decap_3
XFILLER_61_335 VGND VGND VPWR VPWR sky130_fd_sc_hd__fill_1
XFILLER_73_195 VGND VGND VPWR VPWR sky130_fd_sc_hd__decap_3
XTAP_TAPCELL_ROW_29_596 VGND VPWR sky130_fd_sc_hd__tapvpwrvgnd_1
XFILLER_61_346 VGND VGND VPWR VPWR sky130_fd_sc_hd__fill_2
XFILLER_61_357 VGND VGND VPWR VPWR sky130_fd_sc_hd__fill_1
XFILLER_64_83 VGND VGND VPWR VPWR sky130_fd_sc_hd__fill_1
XFILLER_9_12 VGND VGND VPWR VPWR sky130_fd_sc_hd__decap_3
XFILLER_9_45 VGND VGND VPWR VPWR sky130_fd_sc_hd__decap_3
XFILLER_14_284 VGND VGND VPWR VPWR sky130_fd_sc_hd__decap_3
XFILLER_9_78 VGND VGND VPWR VPWR sky130_fd_sc_hd__decap_3
XFILLER_80_71 VGND VGND VPWR VPWR sky130_fd_sc_hd__decap_3
X_3540_ _3502_/A _3502_/B _3485_/C VGND VGND VPWR VPWR _3540_/X sky130_fd_sc_hd__o21a_2
Xhold907 _6696_/Q VGND VGND VPWR VPWR hold907/X sky130_fd_sc_hd__dlygate4sd3_1
Xhold918 _5678_/X VGND VGND VPWR VPWR _6689_/D sky130_fd_sc_hd__dlygate4sd3_1
XFILLER_115_337 VGND VGND VPWR VPWR sky130_fd_sc_hd__decap_3
Xhold929 _6707_/Q VGND VGND VPWR VPWR hold929/X sky130_fd_sc_hd__dlygate4sd3_1
X_3471_ _3545_/A _3545_/B VGND VGND VPWR VPWR _3505_/A sky130_fd_sc_hd__and2b_2
XFILLER_69_435 VGND VGND VPWR VPWR sky130_fd_sc_hd__fill_1
XFILLER_111_532 VGND VGND VPWR VPWR sky130_fd_sc_hd__decap_3
XFILLER_57_608 VGND VGND VPWR VPWR sky130_fd_sc_hd__decap_3
XFILLER_69_457 VGND VGND VPWR VPWR sky130_fd_sc_hd__decap_3
XFILLER_96_243 VGND VGND VPWR VPWR sky130_fd_sc_hd__decap_3
X_5072_ _5072_/A _5072_/B _5072_/C VGND VGND VPWR VPWR _5075_/B sky130_fd_sc_hd__and3_2
XFILLER_56_118 VGND VGND VPWR VPWR sky130_fd_sc_hd__decap_3
XFILLER_84_427 VGND VGND VPWR VPWR sky130_fd_sc_hd__decap_3
XFILLER_96_287 VGND VGND VPWR VPWR sky130_fd_sc_hd__decap_3
XFILLER_49_192 VGND VGND VPWR VPWR sky130_fd_sc_hd__decap_3
XFILLER_65_641 VGND VGND VPWR VPWR sky130_fd_sc_hd__decap_3
XFILLER_25_505 VGND VGND VPWR VPWR sky130_fd_sc_hd__decap_3
XFILLER_65_685 VGND VGND VPWR VPWR sky130_fd_sc_hd__decap_3
XFILLER_80_600 VGND VGND VPWR VPWR sky130_fd_sc_hd__decap_3
XFILLER_52_324 VGND VGND VPWR VPWR sky130_fd_sc_hd__decap_3
XFILLER_64_184 VGND VGND VPWR VPWR sky130_fd_sc_hd__decap_3
XFILLER_80_633 VGND VGND VPWR VPWR sky130_fd_sc_hd__decap_3
XFILLER_40_508 VGND VGND VPWR VPWR sky130_fd_sc_hd__decap_3
XFILLER_52_368 VGND VGND VPWR VPWR sky130_fd_sc_hd__fill_1
XFILLER_100_15 VGND VGND VPWR VPWR sky130_fd_sc_hd__decap_3
X_4925_ _4764_/B _4158_/A _4920_/A _5101_/A _4924_/X VGND VGND VPWR VPWR _4925_/X
+ sky130_fd_sc_hd__o221a_2
XFILLER_100_59 VGND VGND VPWR VPWR sky130_fd_sc_hd__decap_3
X_3807_ _6703_/Q _3878_/A2 _3912_/B1 _6881_/Q VGND VGND VPWR VPWR _3807_/X sky130_fd_sc_hd__a22o_2
X_6526_ _6647_/A VGND VGND VPWR VPWR _6526_/Y sky130_fd_sc_hd__inv_2
X_4787_ _4787_/A _4787_/B VGND VGND VPWR VPWR _4787_/Y sky130_fd_sc_hd__xnor2_2
XFILLER_106_315 VGND VGND VPWR VPWR sky130_fd_sc_hd__fill_1
XFILLER_109_24 VGND VGND VPWR VPWR sky130_fd_sc_hd__decap_3
XFILLER_114_9 VGND VGND VPWR VPWR sky130_fd_sc_hd__decap_3
X_3738_ _6740_/Q _3883_/A2 _3913_/B1 _6734_/Q _3737_/X VGND VGND VPWR VPWR _3738_/X
+ sky130_fd_sc_hd__a221o_2
XFILLER_109_57 VGND VGND VPWR VPWR sky130_fd_sc_hd__decap_3
XFILLER_69_39 VGND VGND VPWR VPWR sky130_fd_sc_hd__decap_3
X_6457_ _6584_/A VGND VGND VPWR VPWR _6457_/Y sky130_fd_sc_hd__inv_2
X_3669_ _6807_/Q _3759_/A2 _3767_/A2 _6717_/Q _3668_/X VGND VGND VPWR VPWR _3669_/X
+ sky130_fd_sc_hd__a221o_2
X_6388_ _6388_/A VGND VGND VPWR VPWR _6388_/Y sky130_fd_sc_hd__inv_2
XFILLER_0_626 VGND VGND VPWR VPWR sky130_fd_sc_hd__decap_3
XFILLER_0_648 VGND VGND VPWR VPWR sky130_fd_sc_hd__decap_3
XFILLER_102_554 VGND VGND VPWR VPWR sky130_fd_sc_hd__fill_1
XFILLER_75_405 VGND VGND VPWR VPWR sky130_fd_sc_hd__decap_3
XFILLER_87_276 VGND VGND VPWR VPWR sky130_fd_sc_hd__decap_3
XTAP_TAPCELL_ROW_89_1317 VGND VPWR sky130_fd_sc_hd__tapvpwrvgnd_1
XFILLER_18_21 VGND VGND VPWR VPWR sky130_fd_sc_hd__decap_3
XFILLER_18_32 VGND VGND VPWR VPWR sky130_fd_sc_hd__decap_3
XFILLER_56_630 VGND VGND VPWR VPWR sky130_fd_sc_hd__decap_3
XFILLER_75_438 VGND VGND VPWR VPWR sky130_fd_sc_hd__decap_3
XFILLER_75_449 VGND VGND VPWR VPWR sky130_fd_sc_hd__decap_3
X_7009_ _7266_/CLK _7009_/D _6289_/Y VGND VGND VPWR VPWR _7009_/Q sky130_fd_sc_hd__dfrtp_2
XFILLER_18_65 VGND VGND VPWR VPWR sky130_fd_sc_hd__decap_3
XFILLER_28_365 VGND VGND VPWR VPWR sky130_fd_sc_hd__fill_1
XFILLER_55_140 VGND VGND VPWR VPWR sky130_fd_sc_hd__decap_3
XFILLER_56_663 VGND VGND VPWR VPWR sky130_fd_sc_hd__decap_3
XFILLER_71_600 VGND VGND VPWR VPWR sky130_fd_sc_hd__decap_3
XTAP_TAPCELL_ROW_46_809 VGND VPWR sky130_fd_sc_hd__tapvpwrvgnd_1
XFILLER_71_644 VGND VGND VPWR VPWR sky130_fd_sc_hd__decap_3
XFILLER_31_508 VGND VGND VPWR VPWR sky130_fd_sc_hd__decap_3
XFILLER_34_20 VGND VGND VPWR VPWR sky130_fd_sc_hd__decap_3
XFILLER_55_195 VGND VGND VPWR VPWR sky130_fd_sc_hd__decap_3
XFILLER_34_42 VGND VGND VPWR VPWR sky130_fd_sc_hd__decap_3
XFILLER_34_53 VGND VGND VPWR VPWR sky130_fd_sc_hd__fill_1
XFILLER_70_187 VGND VGND VPWR VPWR sky130_fd_sc_hd__decap_3
XFILLER_71_688 VGND VGND VPWR VPWR sky130_fd_sc_hd__decap_3
XTAP_TAPCELL_ROW_54_897 VGND VPWR sky130_fd_sc_hd__tapvpwrvgnd_1
XTAP_TAPCELL_ROW_26_566 VGND VPWR sky130_fd_sc_hd__tapvpwrvgnd_1
XFILLER_11_243 VGND VGND VPWR VPWR sky130_fd_sc_hd__decap_3
XFILLER_7_203 VGND VGND VPWR VPWR sky130_fd_sc_hd__decap_3
XFILLER_11_287 VGND VGND VPWR VPWR sky130_fd_sc_hd__decap_3
XFILLER_7_225 VGND VGND VPWR VPWR sky130_fd_sc_hd__decap_3
XFILLER_109_153 VGND VGND VPWR VPWR sky130_fd_sc_hd__fill_2
XFILLER_50_85 VGND VGND VPWR VPWR sky130_fd_sc_hd__decap_3
XFILLER_109_175 VGND VGND VPWR VPWR sky130_fd_sc_hd__decap_3
XFILLER_3_420 VGND VGND VPWR VPWR sky130_fd_sc_hd__decap_3
XFILLER_3_475 VGND VGND VPWR VPWR sky130_fd_sc_hd__decap_3
XFILLER_93_213 VGND VGND VPWR VPWR sky130_fd_sc_hd__decap_3
XFILLER_19_321 VGND VGND VPWR VPWR sky130_fd_sc_hd__decap_3
XFILLER_47_641 VGND VGND VPWR VPWR sky130_fd_sc_hd__decap_3
XFILLER_93_246 VGND VGND VPWR VPWR sky130_fd_sc_hd__fill_1
XFILLER_75_60 VGND VGND VPWR VPWR sky130_fd_sc_hd__decap_3
XFILLER_93_257 VGND VGND VPWR VPWR sky130_fd_sc_hd__decap_3
XTAP_TAPCELL_ROW_109_1564 VGND VPWR sky130_fd_sc_hd__tapvpwrvgnd_1
XFILLER_34_324 VGND VGND VPWR VPWR sky130_fd_sc_hd__fill_1
XFILLER_47_685 VGND VGND VPWR VPWR sky130_fd_sc_hd__decap_3
XFILLER_75_93 VGND VGND VPWR VPWR sky130_fd_sc_hd__decap_3
XFILLER_46_195 VGND VGND VPWR VPWR sky130_fd_sc_hd__fill_1
XFILLER_61_132 VGND VGND VPWR VPWR sky130_fd_sc_hd__decap_3
XFILLER_62_666 VGND VGND VPWR VPWR sky130_fd_sc_hd__decap_3
XFILLER_34_379 VGND VGND VPWR VPWR sky130_fd_sc_hd__decap_3
XFILLER_61_187 VGND VGND VPWR VPWR sky130_fd_sc_hd__decap_3
XFILLER_15_593 VGND VGND VPWR VPWR sky130_fd_sc_hd__decap_3
X_5690_ _7351_/Q hold943/X _5708_/S VGND VGND VPWR VPWR _6695_/D sky130_fd_sc_hd__mux2_2
X_4710_ _7004_/Q _4801_/A VGND VGND VPWR VPWR _4775_/A sky130_fd_sc_hd__and2_2
X_4641_ _4920_/A _4379_/B _4640_/Y _4158_/A VGND VGND VPWR VPWR _4903_/B sky130_fd_sc_hd__o31a_2
X_7360_ _7386_/CLK _7360_/D _6640_/Y VGND VGND VPWR VPWR _7360_/Q sky130_fd_sc_hd__dfrtp_2
XFILLER_116_657 VGND VGND VPWR VPWR sky130_fd_sc_hd__decap_3
XFILLER_6_280 VGND VGND VPWR VPWR sky130_fd_sc_hd__decap_3
X_7291_ clkload6/A _7291_/D _6571_/Y VGND VGND VPWR VPWR _7291_/Q sky130_fd_sc_hd__dfrtp_2
Xhold704 _6835_/Q VGND VGND VPWR VPWR _6835_/D sky130_fd_sc_hd__dlygate4sd3_1
Xhold715 _6804_/Q VGND VGND VPWR VPWR _6804_/D sky130_fd_sc_hd__dlygate4sd3_1
Xhold726 _6740_/Q VGND VGND VPWR VPWR _6740_/D sky130_fd_sc_hd__dlygate4sd3_1
Xhold737 _6819_/Q VGND VGND VPWR VPWR _6819_/D sky130_fd_sc_hd__dlygate4sd3_1
X_6311_ _6660_/A VGND VGND VPWR VPWR _6311_/Y sky130_fd_sc_hd__inv_2
X_3523_ _3505_/A _3458_/Y _3505_/B _3506_/Y _3508_/A VGND VGND VPWR VPWR _3620_/A
+ sky130_fd_sc_hd__o311a_4
XFILLER_103_307 VGND VGND VPWR VPWR sky130_fd_sc_hd__decap_3
XFILLER_115_134 VGND VGND VPWR VPWR sky130_fd_sc_hd__decap_3
XFILLER_115_167 VGND VGND VPWR VPWR sky130_fd_sc_hd__fill_1
XFILLER_116_679 VGND VGND VPWR VPWR sky130_fd_sc_hd__decap_3
Xhold748 _6797_/Q VGND VGND VPWR VPWR _6797_/D sky130_fd_sc_hd__dlygate4sd3_1
Xhold759 _6843_/Q VGND VGND VPWR VPWR _6843_/D sky130_fd_sc_hd__dlygate4sd3_1
X_3454_ _7186_/Q _3996_/S _4534_/S _7031_/Q _3453_/X VGND VGND VPWR VPWR _3454_/X
+ sky130_fd_sc_hd__a221o_2
XTAP_TAPCELL_ROW_73_1129 VGND VPWR sky130_fd_sc_hd__tapvpwrvgnd_1
XFILLER_115_178 VGND VGND VPWR VPWR sky130_fd_sc_hd__decap_3
XFILLER_111_340 VGND VGND VPWR VPWR sky130_fd_sc_hd__decap_3
XFILLER_69_221 VGND VGND VPWR VPWR sky130_fd_sc_hd__decap_3
XFILLER_69_243 VGND VGND VPWR VPWR sky130_fd_sc_hd__decap_3
X_3385_ _5670_/A _5130_/A VGND VGND VPWR VPWR _3385_/Y sky130_fd_sc_hd__nor2_2
XFILLER_111_373 VGND VGND VPWR VPWR sky130_fd_sc_hd__decap_3
XFILLER_29_107 VGND VGND VPWR VPWR sky130_fd_sc_hd__decap_3
X_5124_ _3746_/B _3900_/Y _4677_/B VGND VGND VPWR VPWR _5125_/B sky130_fd_sc_hd__a21o_2
XFILLER_57_449 VGND VGND VPWR VPWR sky130_fd_sc_hd__decap_3
XFILLER_84_224 VGND VGND VPWR VPWR sky130_fd_sc_hd__decap_3
X_5055_ _5146_/B1 _5049_/X _5053_/Y _5054_/Y _4369_/A VGND VGND VPWR VPWR _5055_/X
+ sky130_fd_sc_hd__a221o_2
XFILLER_38_674 VGND VGND VPWR VPWR sky130_fd_sc_hd__decap_3
XFILLER_65_460 VGND VGND VPWR VPWR sky130_fd_sc_hd__decap_3
XFILLER_72_419 VGND VGND VPWR VPWR sky130_fd_sc_hd__fill_1
XFILLER_1_90 VGND VGND VPWR VPWR sky130_fd_sc_hd__decap_3
XFILLER_37_184 VGND VGND VPWR VPWR sky130_fd_sc_hd__decap_3
XFILLER_111_25 VGND VGND VPWR VPWR sky130_fd_sc_hd__decap_3
XFILLER_25_346 VGND VGND VPWR VPWR sky130_fd_sc_hd__decap_3
XFILLER_53_644 VGND VGND VPWR VPWR sky130_fd_sc_hd__decap_3
XFILLER_53_655 VGND VGND VPWR VPWR sky130_fd_sc_hd__fill_1
XFILLER_80_441 VGND VGND VPWR VPWR sky130_fd_sc_hd__decap_3
XTAP_TAPCELL_ROW_84_1258 VGND VPWR sky130_fd_sc_hd__tapvpwrvgnd_1
XFILLER_111_69 VGND VGND VPWR VPWR sky130_fd_sc_hd__decap_3
XFILLER_52_165 VGND VGND VPWR VPWR sky130_fd_sc_hd__decap_3
XFILLER_33_390 VGND VGND VPWR VPWR sky130_fd_sc_hd__fill_2
X_4908_ _4908_/A _4908_/B VGND VGND VPWR VPWR _4909_/C sky130_fd_sc_hd__nor2_2
XTAP_TAPCELL_ROW_23_525 VGND VPWR sky130_fd_sc_hd__tapvpwrvgnd_1
XFILLER_21_541 VGND VGND VPWR VPWR sky130_fd_sc_hd__decap_3
XFILLER_21_552 VGND VGND VPWR VPWR sky130_fd_sc_hd__decap_3
XTAP_TAPCELL_ROW_51_867 VGND VPWR sky130_fd_sc_hd__tapvpwrvgnd_1
X_4839_ _4916_/A _4916_/B _4634_/Y VGND VGND VPWR VPWR _4903_/C sky130_fd_sc_hd__a21o_2
XFILLER_107_613 VGND VGND VPWR VPWR sky130_fd_sc_hd__decap_3
XFILLER_4_206 VGND VGND VPWR VPWR sky130_fd_sc_hd__decap_3
XFILLER_106_112 VGND VGND VPWR VPWR sky130_fd_sc_hd__decap_3
X_6509_ _6576_/A VGND VGND VPWR VPWR _6509_/Y sky130_fd_sc_hd__inv_2
XFILLER_107_668 VGND VGND VPWR VPWR sky130_fd_sc_hd__decap_3
XFILLER_107_679 VGND VGND VPWR VPWR sky130_fd_sc_hd__decap_3
XFILLER_20_44 VGND VGND VPWR VPWR sky130_fd_sc_hd__decap_3
XTAP_TAPCELL_ROW_95_1387 VGND VPWR sky130_fd_sc_hd__tapvpwrvgnd_1
XFILLER_0_412 VGND VGND VPWR VPWR sky130_fd_sc_hd__decap_3
XFILLER_96_26 VGND VGND VPWR VPWR sky130_fd_sc_hd__fill_2
XFILLER_0_467 VGND VGND VPWR VPWR sky130_fd_sc_hd__decap_3
XFILLER_29_42 VGND VGND VPWR VPWR sky130_fd_sc_hd__decap_3
XFILLER_48_416 VGND VGND VPWR VPWR sky130_fd_sc_hd__decap_3
XFILLER_88_574 VGND VGND VPWR VPWR sky130_fd_sc_hd__decap_3
XFILLER_88_585 VGND VGND VPWR VPWR sky130_fd_sc_hd__decap_3
XTAP_TAPCELL_ROW_59_956 VGND VPWR sky130_fd_sc_hd__tapvpwrvgnd_1
XFILLER_16_324 VGND VGND VPWR VPWR sky130_fd_sc_hd__decap_3
XFILLER_28_162 VGND VGND VPWR VPWR sky130_fd_sc_hd__decap_3
XFILLER_44_633 VGND VGND VPWR VPWR sky130_fd_sc_hd__decap_3
XFILLER_45_30 VGND VGND VPWR VPWR sky130_fd_sc_hd__decap_3
XFILLER_56_460 VGND VGND VPWR VPWR sky130_fd_sc_hd__decap_3
Xplace408 _4419_/B1 VGND VGND VPWR VPWR _4196_/A2 sky130_fd_sc_hd__buf_2
Xplace419 _3962_/S VGND VGND VPWR VPWR _3949_/S sky130_fd_sc_hd__buf_2
XTAP_TAPCELL_ROW_3_283 VGND VPWR sky130_fd_sc_hd__tapvpwrvgnd_1
XFILLER_28_195 VGND VGND VPWR VPWR sky130_fd_sc_hd__fill_1
XFILLER_43_143 VGND VGND VPWR VPWR sky130_fd_sc_hd__decap_3
XFILLER_44_666 VGND VGND VPWR VPWR sky130_fd_sc_hd__decap_3
XFILLER_71_452 VGND VGND VPWR VPWR sky130_fd_sc_hd__decap_3
XFILLER_83_290 VGND VGND VPWR VPWR sky130_fd_sc_hd__fill_1
XFILLER_16_368 VGND VGND VPWR VPWR sky130_fd_sc_hd__decap_3
XFILLER_31_349 VGND VGND VPWR VPWR sky130_fd_sc_hd__fill_2
XFILLER_43_198 VGND VGND VPWR VPWR sky130_fd_sc_hd__decap_3
XTAP_TAPCELL_ROW_104_1494 VGND VPWR sky130_fd_sc_hd__tapvpwrvgnd_1
XFILLER_61_40 VGND VGND VPWR VPWR sky130_fd_sc_hd__decap_3
XFILLER_8_512 VGND VGND VPWR VPWR sky130_fd_sc_hd__decap_3
XFILLER_61_84 VGND VGND VPWR VPWR sky130_fd_sc_hd__decap_3
XFILLER_77_9 VGND VGND VPWR VPWR sky130_fd_sc_hd__decap_3
XFILLER_6_24 VGND VGND VPWR VPWR sky130_fd_sc_hd__decap_3
XFILLER_8_589 VGND VGND VPWR VPWR sky130_fd_sc_hd__fill_2
XANTENNA_6 _4367_/C VGND VGND VPWR VPWR sky130_fd_sc_hd__diode_2
XFILLER_6_35 VGND VGND VPWR VPWR sky130_fd_sc_hd__decap_3
XFILLER_6_68 VGND VGND VPWR VPWR sky130_fd_sc_hd__decap_3
XFILLER_112_115 VGND VGND VPWR VPWR sky130_fd_sc_hd__decap_3
XFILLER_113_638 VGND VGND VPWR VPWR sky130_fd_sc_hd__decap_3
XFILLER_106_690 VGND VGND VPWR VPWR sky130_fd_sc_hd__fill_2
XFILLER_112_159 VGND VGND VPWR VPWR sky130_fd_sc_hd__decap_3
XFILLER_94_511 VGND VGND VPWR VPWR sky130_fd_sc_hd__decap_3
XFILLER_86_70 VGND VGND VPWR VPWR sky130_fd_sc_hd__decap_3
XFILLER_66_246 VGND VGND VPWR VPWR sky130_fd_sc_hd__decap_3
XFILLER_66_268 VGND VGND VPWR VPWR sky130_fd_sc_hd__decap_3
XFILLER_94_566 VGND VGND VPWR VPWR sky130_fd_sc_hd__decap_3
XFILLER_19_162 VGND VGND VPWR VPWR sky130_fd_sc_hd__decap_3
XFILLER_19_184 VGND VGND VPWR VPWR sky130_fd_sc_hd__decap_3
XFILLER_62_430 VGND VGND VPWR VPWR sky130_fd_sc_hd__decap_3
X_6860_ _6966_/CLK _6860_/D VGND VGND VPWR VPWR _6860_/Q sky130_fd_sc_hd__dfxtp_2
XFILLER_22_305 VGND VGND VPWR VPWR sky130_fd_sc_hd__decap_3
XFILLER_34_165 VGND VGND VPWR VPWR sky130_fd_sc_hd__decap_3
XFILLER_50_603 VGND VGND VPWR VPWR sky130_fd_sc_hd__decap_3
X_6791_ _6959_/CLK _6791_/D VGND VGND VPWR VPWR _6791_/Q sky130_fd_sc_hd__dfxtp_2
XFILLER_50_636 VGND VGND VPWR VPWR sky130_fd_sc_hd__decap_3
XFILLER_50_669 VGND VGND VPWR VPWR sky130_fd_sc_hd__decap_3
X_7412_ _7412_/A VGND VGND VPWR VPWR _7412_/X sky130_fd_sc_hd__buf_2
X_4624_ _4624_/A _4624_/B VGND VGND VPWR VPWR _4624_/X sky130_fd_sc_hd__and2_2
XPHY_EDGE_ROW_6_Right_6 VGND VGND VPWR VPWR sky130_fd_sc_hd__decap_3
XFILLER_116_421 VGND VGND VPWR VPWR sky130_fd_sc_hd__decap_3
X_7343_ _7386_/CLK _7343_/D _6623_/Y VGND VGND VPWR VPWR _7343_/Q sky130_fd_sc_hd__dfrtp_2
X_3506_ _3544_/A _3506_/B VGND VGND VPWR VPWR _3506_/Y sky130_fd_sc_hd__nand2_2
XFILLER_103_104 VGND VGND VPWR VPWR sky130_fd_sc_hd__decap_3
XFILLER_104_638 VGND VGND VPWR VPWR sky130_fd_sc_hd__decap_3
XFILLER_116_498 VGND VGND VPWR VPWR sky130_fd_sc_hd__decap_3
XFILLER_89_327 VGND VGND VPWR VPWR sky130_fd_sc_hd__decap_3
X_7274_ _7338_/CLK _7274_/D _6554_/Y VGND VGND VPWR VPWR _7274_/Q sky130_fd_sc_hd__dfrtp_2
X_4486_ _4486_/A0 _7304_/Q _4501_/S VGND VGND VPWR VPWR _4486_/X sky130_fd_sc_hd__mux2_2
XFILLER_103_126 VGND VGND VPWR VPWR sky130_fd_sc_hd__decap_3
Xhold589 _6896_/Q VGND VGND VPWR VPWR _6896_/D sky130_fd_sc_hd__dlygate4sd3_1
XFILLER_106_47 VGND VGND VPWR VPWR sky130_fd_sc_hd__decap_3
XFILLER_112_660 VGND VGND VPWR VPWR sky130_fd_sc_hd__decap_3
XFILLER_85_500 VGND VGND VPWR VPWR sky130_fd_sc_hd__decap_3
X_3368_ _3330_/A _5294_/A _3310_/Y _6983_/Q VGND VGND VPWR VPWR _3368_/Y sky130_fd_sc_hd__a211oi_4
XFILLER_111_181 VGND VGND VPWR VPWR sky130_fd_sc_hd__decap_3
XFILLER_66_29 VGND VGND VPWR VPWR sky130_fd_sc_hd__decap_3
XFILLER_85_522 VGND VGND VPWR VPWR sky130_fd_sc_hd__fill_1
XFILLER_85_544 VGND VGND VPWR VPWR sky130_fd_sc_hd__decap_3
XFILLER_97_382 VGND VGND VPWR VPWR sky130_fd_sc_hd__decap_3
XFILLER_97_393 VGND VGND VPWR VPWR sky130_fd_sc_hd__decap_3
Xhold1201 _7134_/Q VGND VGND VPWR VPWR _5398_/A0 sky130_fd_sc_hd__dlygate4sd3_1
Xhold1212 _7247_/Q VGND VGND VPWR VPWR _5159_/A0 sky130_fd_sc_hd__dlygate4sd3_1
X_5107_ _5156_/S _6985_/D _5105_/X _5106_/X VGND VGND VPWR VPWR _5107_/X sky130_fd_sc_hd__o22a_2
X_3299_ _3353_/A _6979_/Q _3371_/A VGND VGND VPWR VPWR _3328_/A sky130_fd_sc_hd__o21a_2
XFILLER_57_279 VGND VGND VPWR VPWR sky130_fd_sc_hd__fill_1
XFILLER_72_205 VGND VGND VPWR VPWR sky130_fd_sc_hd__decap_3
XFILLER_85_588 VGND VGND VPWR VPWR sky130_fd_sc_hd__decap_3
X_5038_ _5038_/A _5038_/B VGND VGND VPWR VPWR _5038_/X sky130_fd_sc_hd__xor2_2
XTAP_TAPCELL_ROW_56_926 VGND VPWR sky130_fd_sc_hd__tapvpwrvgnd_1
XFILLER_65_290 VGND VGND VPWR VPWR sky130_fd_sc_hd__decap_3
XFILLER_72_238 VGND VGND VPWR VPWR sky130_fd_sc_hd__decap_3
XTAP_TAPCELL_ROW_0_253 VGND VPWR sky130_fd_sc_hd__tapvpwrvgnd_1
XTAP_TAPCELL_ROW_0_242 VGND VPWR sky130_fd_sc_hd__tapvpwrvgnd_1
XFILLER_25_143 VGND VGND VPWR VPWR sky130_fd_sc_hd__decap_3
XFILLER_25_165 VGND VGND VPWR VPWR sky130_fd_sc_hd__decap_3
XFILLER_41_603 VGND VGND VPWR VPWR sky130_fd_sc_hd__decap_3
XFILLER_15_33 VGND VGND VPWR VPWR sky130_fd_sc_hd__decap_3
XFILLER_15_66 VGND VGND VPWR VPWR sky130_fd_sc_hd__fill_1
XFILLER_40_135 VGND VGND VPWR VPWR sky130_fd_sc_hd__fill_2
XFILLER_41_647 VGND VGND VPWR VPWR sky130_fd_sc_hd__decap_3
XFILLER_53_496 VGND VGND VPWR VPWR sky130_fd_sc_hd__decap_3
XFILLER_80_293 VGND VGND VPWR VPWR sky130_fd_sc_hd__decap_3
X_6989_ _7338_/CLK _6989_/D _6269_/Y VGND VGND VPWR VPWR _6989_/Q sky130_fd_sc_hd__dfrtp_2
XTAP_TAPCELL_ROW_36_683 VGND VPWR sky130_fd_sc_hd__tapvpwrvgnd_1
XFILLER_40_168 VGND VGND VPWR VPWR sky130_fd_sc_hd__decap_3
XFILLER_21_393 VGND VGND VPWR VPWR sky130_fd_sc_hd__fill_2
XTAP_TAPCELL_ROW_97_1416 VGND VPWR sky130_fd_sc_hd__tapvpwrvgnd_1
XFILLER_110_3 VGND VGND VPWR VPWR sky130_fd_sc_hd__decap_3
XFILLER_31_54 VGND VGND VPWR VPWR sky130_fd_sc_hd__fill_2
XFILLER_107_476 VGND VGND VPWR VPWR sky130_fd_sc_hd__decap_3
XTAP_TAPCELL_ROW_8_353 VGND VPWR sky130_fd_sc_hd__tapvpwrvgnd_1
XTAP_TAPCELL_ROW_8_342 VGND VPWR sky130_fd_sc_hd__tapvpwrvgnd_1
XFILLER_0_231 VGND VGND VPWR VPWR sky130_fd_sc_hd__decap_3
XFILLER_0_253 VGND VGND VPWR VPWR sky130_fd_sc_hd__decap_3
XFILLER_103_660 VGND VGND VPWR VPWR sky130_fd_sc_hd__decap_3
XFILLER_110_619 VGND VGND VPWR VPWR sky130_fd_sc_hd__decap_3
XFILLER_95_308 VGND VGND VPWR VPWR sky130_fd_sc_hd__fill_2
XFILLER_0_297 VGND VGND VPWR VPWR sky130_fd_sc_hd__decap_3
XFILLER_102_170 VGND VGND VPWR VPWR sky130_fd_sc_hd__decap_3
XFILLER_103_682 VGND VGND VPWR VPWR sky130_fd_sc_hd__fill_2
XFILLER_76_533 VGND VGND VPWR VPWR sky130_fd_sc_hd__decap_3
XFILLER_88_393 VGND VGND VPWR VPWR sky130_fd_sc_hd__decap_3
XFILLER_48_246 VGND VGND VPWR VPWR sky130_fd_sc_hd__decap_3
XFILLER_48_268 VGND VGND VPWR VPWR sky130_fd_sc_hd__decap_3
XFILLER_76_566 VGND VGND VPWR VPWR sky130_fd_sc_hd__decap_3
XFILLER_91_503 VGND VGND VPWR VPWR sky130_fd_sc_hd__fill_1
XFILLER_56_51 VGND VGND VPWR VPWR sky130_fd_sc_hd__decap_3
XFILLER_16_121 VGND VGND VPWR VPWR sky130_fd_sc_hd__fill_1
XFILLER_44_441 VGND VGND VPWR VPWR sky130_fd_sc_hd__decap_3
XFILLER_56_95 VGND VGND VPWR VPWR sky130_fd_sc_hd__fill_2
XTAP_TAPCELL_ROW_106_1523 VGND VPWR sky130_fd_sc_hd__tapvpwrvgnd_1
XFILLER_16_165 VGND VGND VPWR VPWR sky130_fd_sc_hd__decap_3
XFILLER_44_463 VGND VGND VPWR VPWR sky130_fd_sc_hd__decap_3
XFILLER_44_474 VGND VGND VPWR VPWR sky130_fd_sc_hd__fill_2
XFILLER_16_187 VGND VGND VPWR VPWR sky130_fd_sc_hd__fill_1
XFILLER_31_113 VGND VGND VPWR VPWR sky130_fd_sc_hd__decap_3
XFILLER_71_293 VGND VGND VPWR VPWR sky130_fd_sc_hd__fill_1
XFILLER_32_669 VGND VGND VPWR VPWR sky130_fd_sc_hd__decap_3
XFILLER_72_72 VGND VGND VPWR VPWR sky130_fd_sc_hd__decap_3
XFILLER_12_360 VGND VGND VPWR VPWR sky130_fd_sc_hd__decap_3
XFILLER_12_382 VGND VGND VPWR VPWR sky130_fd_sc_hd__fill_1
XFILLER_40_680 VGND VGND VPWR VPWR sky130_fd_sc_hd__decap_3
XFILLER_8_320 VGND VGND VPWR VPWR sky130_fd_sc_hd__decap_3
XPHY_EDGE_ROW_59_Right_59 VGND VGND VPWR VPWR sky130_fd_sc_hd__decap_3
XFILLER_75_6 VGND VGND VPWR VPWR sky130_fd_sc_hd__decap_3
XFILLER_113_413 VGND VGND VPWR VPWR sky130_fd_sc_hd__decap_3
XFILLER_4_570 VGND VGND VPWR VPWR sky130_fd_sc_hd__fill_1
X_4340_ _7223_/Q _4340_/A2 _4338_/X _4339_/X VGND VGND VPWR VPWR _4340_/X sky130_fd_sc_hd__a211o_2
XFILLER_99_625 VGND VGND VPWR VPWR sky130_fd_sc_hd__decap_3
XFILLER_98_102 VGND VGND VPWR VPWR sky130_fd_sc_hd__decap_3
XFILLER_113_446 VGND VGND VPWR VPWR sky130_fd_sc_hd__fill_2
XFILLER_4_592 VGND VGND VPWR VPWR sky130_fd_sc_hd__fill_1
X_4271_ _4271_/A _4271_/B _4271_/C _4270_/Y VGND VGND VPWR VPWR _4271_/X sky130_fd_sc_hd__or4b_2
XFILLER_98_135 VGND VGND VPWR VPWR sky130_fd_sc_hd__decap_3
XFILLER_113_479 VGND VGND VPWR VPWR sky130_fd_sc_hd__decap_3
XFILLER_67_522 VGND VGND VPWR VPWR sky130_fd_sc_hd__decap_3
XFILLER_79_393 VGND VGND VPWR VPWR sky130_fd_sc_hd__decap_3
XPHY_EDGE_ROW_68_Right_68 VGND VGND VPWR VPWR sky130_fd_sc_hd__decap_3
XFILLER_39_246 VGND VGND VPWR VPWR sky130_fd_sc_hd__decap_3
XFILLER_67_577 VGND VGND VPWR VPWR sky130_fd_sc_hd__decap_3
XFILLER_39_279 VGND VGND VPWR VPWR sky130_fd_sc_hd__fill_1
XFILLER_54_205 VGND VGND VPWR VPWR sky130_fd_sc_hd__fill_1
XFILLER_82_536 VGND VGND VPWR VPWR sky130_fd_sc_hd__decap_3
XFILLER_94_385 VGND VGND VPWR VPWR sky130_fd_sc_hd__decap_3
XFILLER_54_249 VGND VGND VPWR VPWR sky130_fd_sc_hd__decap_3
X_6912_ _6959_/CLK _6912_/D VGND VGND VPWR VPWR _6912_/Q sky130_fd_sc_hd__dfxtp_2
XFILLER_35_474 VGND VGND VPWR VPWR sky130_fd_sc_hd__decap_3
X_6843_ _6978_/CLK _6843_/D VGND VGND VPWR VPWR _6843_/Q sky130_fd_sc_hd__dfxtp_2
XFILLER_35_485 VGND VGND VPWR VPWR sky130_fd_sc_hd__decap_3
XFILLER_62_282 VGND VGND VPWR VPWR sky130_fd_sc_hd__decap_3
XTAP_TAPCELL_ROW_81_1228 VGND VPWR sky130_fd_sc_hd__tapvpwrvgnd_1
X_6774_ _6911_/CLK _6774_/D VGND VGND VPWR VPWR _6774_/Q sky130_fd_sc_hd__dfxtp_2
XTAP_TAPCELL_ROW_33_653 VGND VPWR sky130_fd_sc_hd__tapvpwrvgnd_1
XTAP_TAPCELL_ROW_33_642 VGND VPWR sky130_fd_sc_hd__tapvpwrvgnd_1
XPHY_EDGE_ROW_77_Right_77 VGND VGND VPWR VPWR sky130_fd_sc_hd__decap_3
XFILLER_50_477 VGND VGND VPWR VPWR sky130_fd_sc_hd__decap_3
X_5725_ _7368_/Q hold949/X _5737_/S VGND VGND VPWR VPWR _6712_/D sky130_fd_sc_hd__mux2_2
XTAP_TAPCELL_ROW_61_984 VGND VPWR sky130_fd_sc_hd__tapvpwrvgnd_1
X_5656_ _5656_/A _5656_/B _5656_/C VGND VGND VPWR VPWR _5665_/C sky130_fd_sc_hd__nor3_2
XFILLER_116_240 VGND VGND VPWR VPWR sky130_fd_sc_hd__decap_3
X_5587_ _5587_/A _5587_/B VGND VGND VPWR VPWR _7034_/D sky130_fd_sc_hd__and2_2
XFILLER_104_402 VGND VGND VPWR VPWR sky130_fd_sc_hd__decap_3
XFILLER_116_273 VGND VGND VPWR VPWR sky130_fd_sc_hd__decap_3
XFILLER_89_102 VGND VGND VPWR VPWR sky130_fd_sc_hd__fill_2
X_7326_ _7358_/CLK _7326_/D _6606_/Y VGND VGND VPWR VPWR _7326_/Q sky130_fd_sc_hd__dfrtp_2
XFILLER_104_424 VGND VGND VPWR VPWR sky130_fd_sc_hd__decap_3
XFILLER_116_295 VGND VGND VPWR VPWR sky130_fd_sc_hd__decap_3
XFILLER_7_9 VGND VGND VPWR VPWR sky130_fd_sc_hd__decap_3
X_7257_ _7279_/CLK _7257_/D _6537_/Y VGND VGND VPWR VPWR _7257_/Q sky130_fd_sc_hd__dfrtp_2
X_4469_ _7009_/Q _4467_/A _4469_/A3 _4468_/X VGND VGND VPWR VPWR _4469_/X sky130_fd_sc_hd__a31o_2
XTAP_TAPCELL_ROW_92_1357 VGND VPWR sky130_fd_sc_hd__tapvpwrvgnd_1
XFILLER_77_39 VGND VGND VPWR VPWR sky130_fd_sc_hd__decap_3
XTAP_TAPCELL_ROW_5_312 VGND VPWR sky130_fd_sc_hd__tapvpwrvgnd_1
XPHY_EDGE_ROW_86_Right_86 VGND VGND VPWR VPWR sky130_fd_sc_hd__decap_3
XFILLER_58_533 VGND VGND VPWR VPWR sky130_fd_sc_hd__decap_3
X_7188_ clkload8/A _7188_/D _6468_/Y VGND VGND VPWR VPWR _7188_/Q sky130_fd_sc_hd__dfrtp_2
XFILLER_100_663 VGND VGND VPWR VPWR sky130_fd_sc_hd__decap_3
XFILLER_85_330 VGND VGND VPWR VPWR sky130_fd_sc_hd__decap_3
XFILLER_85_352 VGND VGND VPWR VPWR sky130_fd_sc_hd__decap_3
Xhold1020 _7193_/Q VGND VGND VPWR VPWR _5274_/A0 sky130_fd_sc_hd__dlygate4sd3_1
Xhold1031 _7270_/Q VGND VGND VPWR VPWR _4865_/A0 sky130_fd_sc_hd__dlygate4sd3_1
Xhold1042 _7195_/Q VGND VGND VPWR VPWR _5270_/A0 sky130_fd_sc_hd__dlygate4sd3_1
XFILLER_18_419 VGND VGND VPWR VPWR sky130_fd_sc_hd__fill_1
XFILLER_85_363 VGND VGND VPWR VPWR sky130_fd_sc_hd__decap_3
XFILLER_85_396 VGND VGND VPWR VPWR sky130_fd_sc_hd__decap_3
XFILLER_93_27 VGND VGND VPWR VPWR sky130_fd_sc_hd__decap_3
Xhold1053 _7184_/Q VGND VGND VPWR VPWR _5290_/A0 sky130_fd_sc_hd__dlygate4sd3_1
Xhold1064 _7269_/Q VGND VGND VPWR VPWR _4879_/A0 sky130_fd_sc_hd__dlygate4sd3_1
Xhold1075 _7278_/Q VGND VGND VPWR VPWR _4718_/A0 sky130_fd_sc_hd__dlygate4sd3_1
XFILLER_26_21 VGND VGND VPWR VPWR sky130_fd_sc_hd__fill_2
XFILLER_26_32 VGND VGND VPWR VPWR sky130_fd_sc_hd__fill_1
XFILLER_26_430 VGND VGND VPWR VPWR sky130_fd_sc_hd__decap_3
XFILLER_45_249 VGND VGND VPWR VPWR sky130_fd_sc_hd__decap_3
Xhold1086 _7341_/Q VGND VGND VPWR VPWR _4476_/A0 sky130_fd_sc_hd__dlygate4sd3_1
Xhold1097 _7402_/Q VGND VGND VPWR VPWR _3698_/A1 sky130_fd_sc_hd__dlygate4sd3_1
XFILLER_26_474 VGND VGND VPWR VPWR sky130_fd_sc_hd__fill_2
XFILLER_13_124 VGND VGND VPWR VPWR sky130_fd_sc_hd__fill_2
XPHY_EDGE_ROW_95_Right_95 VGND VGND VPWR VPWR sky130_fd_sc_hd__decap_3
XFILLER_41_444 VGND VGND VPWR VPWR sky130_fd_sc_hd__decap_3
XTAP_TAPCELL_ROW_101_1464 VGND VPWR sky130_fd_sc_hd__tapvpwrvgnd_1
XFILLER_9_139 VGND VGND VPWR VPWR sky130_fd_sc_hd__decap_3
XFILLER_21_190 VGND VGND VPWR VPWR sky130_fd_sc_hd__decap_3
XFILLER_5_323 VGND VGND VPWR VPWR sky130_fd_sc_hd__decap_3
XPHY_EDGE_ROW_39_Left_156 VGND VGND VPWR VPWR sky130_fd_sc_hd__decap_3
XFILLER_107_284 VGND VGND VPWR VPWR sky130_fd_sc_hd__decap_3
XFILLER_3_36 VGND VGND VPWR VPWR sky130_fd_sc_hd__decap_3
XFILLER_49_500 VGND VGND VPWR VPWR sky130_fd_sc_hd__decap_3
XFILLER_68_319 VGND VGND VPWR VPWR sky130_fd_sc_hd__decap_3
XFILLER_95_105 VGND VGND VPWR VPWR sky130_fd_sc_hd__decap_3
XFILLER_107_90 VGND VGND VPWR VPWR sky130_fd_sc_hd__decap_3
XFILLER_110_438 VGND VGND VPWR VPWR sky130_fd_sc_hd__fill_1
XFILLER_1_595 VGND VGND VPWR VPWR sky130_fd_sc_hd__decap_3
XFILLER_3_69 VGND VGND VPWR VPWR sky130_fd_sc_hd__decap_3
XFILLER_89_691 VGND VGND VPWR VPWR sky130_fd_sc_hd__fill_1
XFILLER_95_116 VGND VGND VPWR VPWR sky130_fd_sc_hd__fill_2
XFILLER_95_138 VGND VGND VPWR VPWR sky130_fd_sc_hd__decap_3
XTAP_TAPCELL_ROW_112_1593 VGND VPWR sky130_fd_sc_hd__tapvpwrvgnd_1
XFILLER_76_330 VGND VGND VPWR VPWR sky130_fd_sc_hd__decap_3
XFILLER_49_599 VGND VGND VPWR VPWR sky130_fd_sc_hd__decap_3
XFILLER_76_363 VGND VGND VPWR VPWR sky130_fd_sc_hd__fill_1
XFILLER_29_290 VGND VGND VPWR VPWR sky130_fd_sc_hd__decap_3
XFILLER_91_333 VGND VGND VPWR VPWR sky130_fd_sc_hd__decap_3
XPHY_EDGE_ROW_48_Left_165 VGND VGND VPWR VPWR sky130_fd_sc_hd__decap_3
XFILLER_17_452 VGND VGND VPWR VPWR sky130_fd_sc_hd__decap_3
XFILLER_83_60 VGND VGND VPWR VPWR sky130_fd_sc_hd__decap_3
XTAP_TAPCELL_ROW_67_1061 VGND VPWR sky130_fd_sc_hd__tapvpwrvgnd_1
XTAP_TAPCELL_ROW_67_1050 VGND VPWR sky130_fd_sc_hd__tapvpwrvgnd_1
XFILLER_91_399 VGND VGND VPWR VPWR sky130_fd_sc_hd__decap_3
XFILLER_20_606 VGND VGND VPWR VPWR sky130_fd_sc_hd__fill_2
XFILLER_44_293 VGND VGND VPWR VPWR sky130_fd_sc_hd__decap_3
X_3840_ _6835_/Q _3886_/B1 _3665_/X _6840_/Q VGND VGND VPWR VPWR _3840_/X sky130_fd_sc_hd__a22o_2
XFILLER_32_477 VGND VGND VPWR VPWR sky130_fd_sc_hd__decap_3
X_3771_ _6910_/Q _3879_/A2 _3889_/A2 _6862_/Q VGND VGND VPWR VPWR _3771_/X sky130_fd_sc_hd__a22o_2
XTAP_TAPCELL_ROW_30_612 VGND VPWR sky130_fd_sc_hd__tapvpwrvgnd_1
XFILLER_13_691 VGND VGND VPWR VPWR sky130_fd_sc_hd__fill_1
XFILLER_9_651 VGND VGND VPWR VPWR sky130_fd_sc_hd__fill_2
XFILLER_73_3 VGND VGND VPWR VPWR sky130_fd_sc_hd__decap_3
XFILLER_8_150 VGND VGND VPWR VPWR sky130_fd_sc_hd__decap_3
X_6490_ _6548_/A VGND VGND VPWR VPWR _6490_/Y sky130_fd_sc_hd__inv_2
XFILLER_9_673 VGND VGND VPWR VPWR sky130_fd_sc_hd__decap_3
XPHY_EDGE_ROW_57_Left_174 VGND VGND VPWR VPWR sky130_fd_sc_hd__decap_3
XTAP_TAPCELL_ROW_78_1190 VGND VPWR sky130_fd_sc_hd__tapvpwrvgnd_1
X_7111_ _7369_/CLK _7111_/D _6391_/Y VGND VGND VPWR VPWR _7111_/Q sky130_fd_sc_hd__dfrtp_2
Xoutput469 _5662_/C VGND VGND VPWR VPWR alu_result_out[17] sky130_fd_sc_hd__clkdlybuf4s25_1
X_4323_ _7226_/Q _4469_/A3 _3968_/S _7194_/Q VGND VGND VPWR VPWR _4323_/X sky130_fd_sc_hd__a22o_2
XFILLER_99_422 VGND VGND VPWR VPWR sky130_fd_sc_hd__decap_3
XFILLER_101_405 VGND VGND VPWR VPWR sky130_fd_sc_hd__decap_3
XFILLER_113_243 VGND VGND VPWR VPWR sky130_fd_sc_hd__decap_3
XFILLER_59_308 VGND VGND VPWR VPWR sky130_fd_sc_hd__decap_3
X_7042_ _7230_/CLK _7042_/D _6322_/Y VGND VGND VPWR VPWR _7042_/Q sky130_fd_sc_hd__dfrtp_2
XFILLER_99_477 VGND VGND VPWR VPWR sky130_fd_sc_hd__decap_3
XFILLER_101_438 VGND VGND VPWR VPWR sky130_fd_sc_hd__decap_3
XFILLER_113_276 VGND VGND VPWR VPWR sky130_fd_sc_hd__decap_3
XFILLER_113_287 VGND VGND VPWR VPWR sky130_fd_sc_hd__decap_3
XFILLER_86_127 VGND VGND VPWR VPWR sky130_fd_sc_hd__decap_3
X_4254_ _7229_/Q _4469_/A3 _4503_/S _7042_/Q _4253_/X VGND VGND VPWR VPWR _4254_/X
+ sky130_fd_sc_hd__a221o_2
XFILLER_101_449 VGND VGND VPWR VPWR sky130_fd_sc_hd__decap_3
XFILLER_67_330 VGND VGND VPWR VPWR sky130_fd_sc_hd__decap_3
XFILLER_79_190 VGND VGND VPWR VPWR sky130_fd_sc_hd__decap_3
X_4185_ _4537_/C _4289_/B _4185_/C VGND VGND VPWR VPWR _4636_/B sky130_fd_sc_hd__and3_2
XFILLER_103_15 VGND VGND VPWR VPWR sky130_fd_sc_hd__decap_3
XFILLER_67_385 VGND VGND VPWR VPWR sky130_fd_sc_hd__decap_3
XTAP_TAPCELL_ROW_38_712 VGND VPWR sky130_fd_sc_hd__tapvpwrvgnd_1
XPHY_EDGE_ROW_66_Left_183 VGND VGND VPWR VPWR sky130_fd_sc_hd__decap_3
XFILLER_103_48 VGND VGND VPWR VPWR sky130_fd_sc_hd__decap_3
XFILLER_55_558 VGND VGND VPWR VPWR sky130_fd_sc_hd__fill_2
XFILLER_82_333 VGND VGND VPWR VPWR sky130_fd_sc_hd__decap_3
XFILLER_82_377 VGND VGND VPWR VPWR sky130_fd_sc_hd__decap_3
XFILLER_23_433 VGND VGND VPWR VPWR sky130_fd_sc_hd__decap_3
X_6826_ _6929_/CLK _6826_/D VGND VGND VPWR VPWR _6826_/Q sky130_fd_sc_hd__dfxtp_2
XFILLER_23_477 VGND VGND VPWR VPWR sky130_fd_sc_hd__decap_3
X_6757_ _6976_/CLK _6757_/D VGND VGND VPWR VPWR _6757_/Q sky130_fd_sc_hd__dfxtp_2
XFILLER_109_505 VGND VGND VPWR VPWR sky130_fd_sc_hd__decap_3
XFILLER_10_138 VGND VGND VPWR VPWR sky130_fd_sc_hd__fill_2
XFILLER_12_12 VGND VGND VPWR VPWR sky130_fd_sc_hd__decap_3
X_5708_ _7360_/Q hold932/X _5708_/S VGND VGND VPWR VPWR _6704_/D sky130_fd_sc_hd__mux2_2
XFILLER_6_109 VGND VGND VPWR VPWR sky130_fd_sc_hd__decap_3
X_6688_ _7387_/CLK _6688_/D VGND VGND VPWR VPWR _6688_/Q sky130_fd_sc_hd__dfxtp_2
XPHY_EDGE_ROW_75_Left_192 VGND VGND VPWR VPWR sky130_fd_sc_hd__decap_3
XFILLER_12_56 VGND VGND VPWR VPWR sky130_fd_sc_hd__decap_3
XFILLER_88_27 VGND VGND VPWR VPWR sky130_fd_sc_hd__fill_1
XFILLER_5_6 VGND VGND VPWR VPWR sky130_fd_sc_hd__decap_3
XFILLER_88_49 VGND VGND VPWR VPWR sky130_fd_sc_hd__fill_2
X_7309_ _7341_/CLK _7309_/D _6589_/Y VGND VGND VPWR VPWR _7309_/Q sky130_fd_sc_hd__dfrtp_2
XFILLER_104_265 VGND VGND VPWR VPWR sky130_fd_sc_hd__fill_1
XFILLER_2_359 VGND VGND VPWR VPWR sky130_fd_sc_hd__decap_3
XFILLER_78_606 VGND VGND VPWR VPWR sky130_fd_sc_hd__fill_1
XFILLER_78_628 VGND VGND VPWR VPWR sky130_fd_sc_hd__decap_3
XFILLER_104_287 VGND VGND VPWR VPWR sky130_fd_sc_hd__decap_3
XFILLER_58_330 VGND VGND VPWR VPWR sky130_fd_sc_hd__decap_3
XFILLER_58_341 VGND VGND VPWR VPWR sky130_fd_sc_hd__decap_3
XFILLER_86_683 VGND VGND VPWR VPWR sky130_fd_sc_hd__decap_3
XFILLER_18_227 VGND VGND VPWR VPWR sky130_fd_sc_hd__decap_3
XFILLER_46_536 VGND VGND VPWR VPWR sky130_fd_sc_hd__decap_3
XFILLER_73_333 VGND VGND VPWR VPWR sky130_fd_sc_hd__decap_3
XFILLER_73_344 VGND VGND VPWR VPWR sky130_fd_sc_hd__decap_3
XFILLER_33_208 VGND VGND VPWR VPWR sky130_fd_sc_hd__decap_3
XFILLER_26_271 VGND VGND VPWR VPWR sky130_fd_sc_hd__decap_3
XFILLER_54_580 VGND VGND VPWR VPWR sky130_fd_sc_hd__decap_3
XTAP_TAPCELL_ROW_16_439 VGND VPWR sky130_fd_sc_hd__tapvpwrvgnd_1
XFILLER_53_30 VGND VGND VPWR VPWR sky130_fd_sc_hd__decap_3
XFILLER_53_63 VGND VGND VPWR VPWR sky130_fd_sc_hd__decap_3
XFILLER_14_477 VGND VGND VPWR VPWR sky130_fd_sc_hd__decap_3
XFILLER_14_499 VGND VGND VPWR VPWR sky130_fd_sc_hd__decap_3
XFILLER_41_252 VGND VGND VPWR VPWR sky130_fd_sc_hd__decap_3
XFILLER_41_296 VGND VGND VPWR VPWR sky130_fd_sc_hd__decap_3
XFILLER_10_661 VGND VGND VPWR VPWR sky130_fd_sc_hd__fill_2
XFILLER_6_654 VGND VGND VPWR VPWR sky130_fd_sc_hd__decap_3
XFILLER_5_142 VGND VGND VPWR VPWR sky130_fd_sc_hd__decap_3
XFILLER_6_687 VGND VGND VPWR VPWR sky130_fd_sc_hd__decap_3
XTAP_TAPCELL_ROW_114_1622 VGND VPWR sky130_fd_sc_hd__tapvpwrvgnd_1
XFILLER_5_175 VGND VGND VPWR VPWR sky130_fd_sc_hd__decap_3
XFILLER_5_197 VGND VGND VPWR VPWR sky130_fd_sc_hd__decap_3
XFILLER_69_606 VGND VGND VPWR VPWR sky130_fd_sc_hd__decap_3
XFILLER_96_403 VGND VGND VPWR VPWR sky130_fd_sc_hd__decap_3
XFILLER_38_6 VGND VGND VPWR VPWR sky130_fd_sc_hd__decap_3
XFILLER_68_127 VGND VGND VPWR VPWR sky130_fd_sc_hd__decap_3
XFILLER_78_82 VGND VGND VPWR VPWR sky130_fd_sc_hd__fill_2
XFILLER_110_235 VGND VGND VPWR VPWR sky130_fd_sc_hd__decap_3
XFILLER_1_381 VGND VGND VPWR VPWR sky130_fd_sc_hd__decap_3
XFILLER_96_469 VGND VGND VPWR VPWR sky130_fd_sc_hd__decap_3
XFILLER_64_300 VGND VGND VPWR VPWR sky130_fd_sc_hd__decap_3
XFILLER_83_119 VGND VGND VPWR VPWR sky130_fd_sc_hd__decap_3
XFILLER_37_536 VGND VGND VPWR VPWR sky130_fd_sc_hd__fill_1
XFILLER_49_396 VGND VGND VPWR VPWR sky130_fd_sc_hd__decap_3
XFILLER_76_193 VGND VGND VPWR VPWR sky130_fd_sc_hd__decap_3
XFILLER_92_631 VGND VGND VPWR VPWR sky130_fd_sc_hd__decap_3
XFILLER_94_70 VGND VGND VPWR VPWR sky130_fd_sc_hd__decap_3
XFILLER_64_377 VGND VGND VPWR VPWR sky130_fd_sc_hd__decap_3
XFILLER_91_152 VGND VGND VPWR VPWR sky130_fd_sc_hd__decap_3
XFILLER_92_675 VGND VGND VPWR VPWR sky130_fd_sc_hd__decap_3
X_4941_ _4811_/C _4936_/Y _4940_/Y VGND VGND VPWR VPWR _5657_/C sky130_fd_sc_hd__a21o_2
XFILLER_32_241 VGND VGND VPWR VPWR sky130_fd_sc_hd__decap_3
X_4872_ _4872_/A _4872_/B VGND VGND VPWR VPWR _4872_/X sky130_fd_sc_hd__and2_2
X_6611_ _6611_/A VGND VGND VPWR VPWR _6611_/Y sky130_fd_sc_hd__inv_2
X_3823_ _6947_/Q _5660_/B _3826_/B1 _6959_/Q VGND VGND VPWR VPWR _3823_/X sky130_fd_sc_hd__a22o_2
XTAP_TAPCELL_ROW_43_770 VGND VPWR sky130_fd_sc_hd__tapvpwrvgnd_1
X_6542_ _6548_/A VGND VGND VPWR VPWR _6542_/Y sky130_fd_sc_hd__inv_2
X_3754_ hold999/X _4799_/A _3753_/X VGND VGND VPWR VPWR _7397_/D sky130_fd_sc_hd__o21a_2
X_6473_ _6576_/A VGND VGND VPWR VPWR _6473_/Y sky130_fd_sc_hd__inv_2
XFILLER_114_530 VGND VGND VPWR VPWR sky130_fd_sc_hd__fill_2
XFILLER_114_563 VGND VGND VPWR VPWR sky130_fd_sc_hd__decap_3
XFILLER_58_19 VGND VGND VPWR VPWR sky130_fd_sc_hd__decap_3
XFILLER_87_436 VGND VGND VPWR VPWR sky130_fd_sc_hd__decap_3
X_5286_ _5286_/A0 _5139_/X _5292_/S VGND VGND VPWR VPWR _7186_/D sky130_fd_sc_hd__mux2_2
X_4306_ _7288_/Q _5136_/S _3417_/X _7096_/Q VGND VGND VPWR VPWR _4311_/A sky130_fd_sc_hd__a22o_2
XFILLER_99_296 VGND VGND VPWR VPWR sky130_fd_sc_hd__decap_3
XFILLER_59_138 VGND VGND VPWR VPWR sky130_fd_sc_hd__decap_3
X_7025_ _7369_/CLK _7025_/D _6305_/Y VGND VGND VPWR VPWR _7025_/Q sky130_fd_sc_hd__dfrtp_2
X_4237_ _7259_/Q _4601_/S _4236_/X VGND VGND VPWR VPWR _4237_/X sky130_fd_sc_hd__a21o_2
XFILLER_114_47 VGND VGND VPWR VPWR sky130_fd_sc_hd__decap_3
XFILLER_74_108 VGND VGND VPWR VPWR sky130_fd_sc_hd__decap_3
XFILLER_28_536 VGND VGND VPWR VPWR sky130_fd_sc_hd__fill_1
XFILLER_55_333 VGND VGND VPWR VPWR sky130_fd_sc_hd__decap_3
XFILLER_74_29 VGND VGND VPWR VPWR sky130_fd_sc_hd__decap_3
XFILLER_95_491 VGND VGND VPWR VPWR sky130_fd_sc_hd__decap_3
X_4168_ _7046_/Q _4499_/S _4394_/B _7361_/Q _4167_/X VGND VGND VPWR VPWR _4168_/X
+ sky130_fd_sc_hd__a221o_2
XFILLER_15_208 VGND VGND VPWR VPWR sky130_fd_sc_hd__decap_3
XFILLER_82_130 VGND VGND VPWR VPWR sky130_fd_sc_hd__decap_3
XFILLER_83_653 VGND VGND VPWR VPWR sky130_fd_sc_hd__decap_3
X_4099_ _7301_/Q _4499_/S _4459_/C1 _7173_/Q _4098_/X VGND VGND VPWR VPWR _4099_/X
+ sky130_fd_sc_hd__a221o_2
XFILLER_82_174 VGND VGND VPWR VPWR sky130_fd_sc_hd__decap_3
XFILLER_70_358 VGND VGND VPWR VPWR sky130_fd_sc_hd__decap_3
XFILLER_90_17 VGND VGND VPWR VPWR sky130_fd_sc_hd__decap_3
XFILLER_11_414 VGND VGND VPWR VPWR sky130_fd_sc_hd__decap_3
XFILLER_23_274 VGND VGND VPWR VPWR sky130_fd_sc_hd__decap_3
X_6809_ _6966_/CLK _6809_/D VGND VGND VPWR VPWR _6809_/Q sky130_fd_sc_hd__dfxtp_2
XTAP_TAPCELL_ROW_13_409 VGND VPWR sky130_fd_sc_hd__tapvpwrvgnd_1
XPHY_EDGE_ROW_83_Left_200 VGND VGND VPWR VPWR sky130_fd_sc_hd__decap_3
XFILLER_11_447 VGND VGND VPWR VPWR sky130_fd_sc_hd__fill_1
XFILLER_23_66 VGND VGND VPWR VPWR sky130_fd_sc_hd__decap_3
XFILLER_7_429 VGND VGND VPWR VPWR sky130_fd_sc_hd__fill_1
XFILLER_23_99 VGND VGND VPWR VPWR sky130_fd_sc_hd__decap_3
XFILLER_99_15 VGND VGND VPWR VPWR sky130_fd_sc_hd__decap_3
XFILLER_99_48 VGND VGND VPWR VPWR sky130_fd_sc_hd__decap_3
XFILLER_2_112 VGND VGND VPWR VPWR sky130_fd_sc_hd__decap_3
XFILLER_3_635 VGND VGND VPWR VPWR sky130_fd_sc_hd__decap_3
XFILLER_105_552 VGND VGND VPWR VPWR sky130_fd_sc_hd__decap_3
XFILLER_2_156 VGND VGND VPWR VPWR sky130_fd_sc_hd__fill_1
XFILLER_3_3 VGND VGND VPWR VPWR sky130_fd_sc_hd__decap_3
XFILLER_3_668 VGND VGND VPWR VPWR sky130_fd_sc_hd__decap_3
XFILLER_3_679 VGND VGND VPWR VPWR sky130_fd_sc_hd__decap_3
XFILLER_105_585 VGND VGND VPWR VPWR sky130_fd_sc_hd__decap_3
XFILLER_78_436 VGND VGND VPWR VPWR sky130_fd_sc_hd__fill_1
XFILLER_48_41 VGND VGND VPWR VPWR sky130_fd_sc_hd__decap_3
XFILLER_48_52 VGND VGND VPWR VPWR sky130_fd_sc_hd__decap_3
XFILLER_59_650 VGND VGND VPWR VPWR sky130_fd_sc_hd__decap_3
XFILLER_65_119 VGND VGND VPWR VPWR sky130_fd_sc_hd__decap_3
XFILLER_58_171 VGND VGND VPWR VPWR sky130_fd_sc_hd__decap_3
XFILLER_86_480 VGND VGND VPWR VPWR sky130_fd_sc_hd__fill_2
XFILLER_100_290 VGND VGND VPWR VPWR sky130_fd_sc_hd__decap_3
XFILLER_46_344 VGND VGND VPWR VPWR sky130_fd_sc_hd__decap_3
XFILLER_73_152 VGND VGND VPWR VPWR sky130_fd_sc_hd__decap_3
XFILLER_104_91 VGND VGND VPWR VPWR sky130_fd_sc_hd__decap_3
XFILLER_61_314 VGND VGND VPWR VPWR sky130_fd_sc_hd__decap_3
XFILLER_64_62 VGND VGND VPWR VPWR sky130_fd_sc_hd__decap_3
XTAP_TAPCELL_ROW_29_597 VGND VPWR sky130_fd_sc_hd__tapvpwrvgnd_1
XFILLER_14_230 VGND VGND VPWR VPWR sky130_fd_sc_hd__decap_3
XFILLER_61_369 VGND VGND VPWR VPWR sky130_fd_sc_hd__decap_3
XTAP_TAPCELL_ROW_64_1020 VGND VPWR sky130_fd_sc_hd__tapvpwrvgnd_1
XFILLER_9_24 VGND VGND VPWR VPWR sky130_fd_sc_hd__decap_3
XFILLER_14_296 VGND VGND VPWR VPWR sky130_fd_sc_hd__decap_3
XFILLER_80_50 VGND VGND VPWR VPWR sky130_fd_sc_hd__decap_3
XFILLER_9_57 VGND VGND VPWR VPWR sky130_fd_sc_hd__decap_3
XFILLER_115_305 VGND VGND VPWR VPWR sky130_fd_sc_hd__decap_3
Xhold908 _6697_/Q VGND VGND VPWR VPWR hold908/X sky130_fd_sc_hd__dlygate4sd3_1
Xhold919 _6709_/Q VGND VGND VPWR VPWR hold919/X sky130_fd_sc_hd__dlygate4sd3_1
XFILLER_115_349 VGND VGND VPWR VPWR sky130_fd_sc_hd__decap_3
X_3470_ _3468_/X _3424_/S _4537_/C _4537_/B VGND VGND VPWR VPWR _3545_/B sky130_fd_sc_hd__o2bb2a_2
XFILLER_111_511 VGND VGND VPWR VPWR sky130_fd_sc_hd__decap_3
XFILLER_36_3 VGND VGND VPWR VPWR sky130_fd_sc_hd__decap_3
XFILLER_96_200 VGND VGND VPWR VPWR sky130_fd_sc_hd__fill_2
X_5140_ _5140_/A0 _5139_/X _5159_/S VGND VGND VPWR VPWR _7250_/D sky130_fd_sc_hd__mux2_2
XFILLER_2_690 VGND VGND VPWR VPWR sky130_fd_sc_hd__fill_2
XFILLER_69_469 VGND VGND VPWR VPWR sky130_fd_sc_hd__decap_3
X_5071_ _5071_/A _5071_/B VGND VGND VPWR VPWR _5072_/C sky130_fd_sc_hd__nand2_2
XFILLER_111_588 VGND VGND VPWR VPWR sky130_fd_sc_hd__decap_3
XFILLER_37_300 VGND VGND VPWR VPWR sky130_fd_sc_hd__fill_1
XFILLER_84_417 VGND VGND VPWR VPWR sky130_fd_sc_hd__decap_3
XFILLER_65_620 VGND VGND VPWR VPWR sky130_fd_sc_hd__decap_3
XFILLER_77_491 VGND VGND VPWR VPWR sky130_fd_sc_hd__decap_3
XFILLER_84_439 VGND VGND VPWR VPWR sky130_fd_sc_hd__decap_3
XFILLER_96_299 VGND VGND VPWR VPWR sky130_fd_sc_hd__decap_3
XFILLER_37_366 VGND VGND VPWR VPWR sky130_fd_sc_hd__decap_3
XFILLER_65_653 VGND VGND VPWR VPWR sky130_fd_sc_hd__decap_3
XFILLER_37_377 VGND VGND VPWR VPWR sky130_fd_sc_hd__fill_1
XFILLER_80_612 VGND VGND VPWR VPWR sky130_fd_sc_hd__fill_1
XFILLER_92_472 VGND VGND VPWR VPWR sky130_fd_sc_hd__decap_3
XFILLER_92_483 VGND VGND VPWR VPWR sky130_fd_sc_hd__decap_3
XFILLER_52_336 VGND VGND VPWR VPWR sky130_fd_sc_hd__decap_3
XFILLER_80_678 VGND VGND VPWR VPWR sky130_fd_sc_hd__decap_3
X_4924_ _4920_/A _4922_/X _4923_/Y VGND VGND VPWR VPWR _4924_/X sky130_fd_sc_hd__a21o_2
XFILLER_100_27 VGND VGND VPWR VPWR sky130_fd_sc_hd__fill_1
XFILLER_100_38 VGND VGND VPWR VPWR sky130_fd_sc_hd__decap_3
XFILLER_20_200 VGND VGND VPWR VPWR sky130_fd_sc_hd__decap_3
XFILLER_60_380 VGND VGND VPWR VPWR sky130_fd_sc_hd__decap_3
X_4855_ _4855_/A _4855_/B _4854_/X VGND VGND VPWR VPWR _5655_/D sky130_fd_sc_hd__or3b_4
XFILLER_20_266 VGND VGND VPWR VPWR sky130_fd_sc_hd__decap_3
X_4786_ _4795_/A _4795_/B _4648_/A VGND VGND VPWR VPWR _4787_/B sky130_fd_sc_hd__a21o_2
X_3806_ _6966_/Q _3884_/A2 _3883_/A2 _6954_/Q _3805_/X VGND VGND VPWR VPWR _3806_/X
+ sky130_fd_sc_hd__a221o_2
X_6525_ _6525_/A VGND VGND VPWR VPWR _6525_/Y sky130_fd_sc_hd__inv_2
X_3737_ _6752_/Q _3884_/A2 _3912_/B1 _6746_/Q VGND VGND VPWR VPWR _3737_/X sky130_fd_sc_hd__a22o_2
XFILLER_109_36 VGND VGND VPWR VPWR sky130_fd_sc_hd__decap_3
XFILLER_106_327 VGND VGND VPWR VPWR sky130_fd_sc_hd__decap_3
XFILLER_109_69 VGND VGND VPWR VPWR sky130_fd_sc_hd__decap_3
XFILLER_69_18 VGND VGND VPWR VPWR sky130_fd_sc_hd__decap_3
X_6456_ _6616_/A VGND VGND VPWR VPWR _6456_/Y sky130_fd_sc_hd__inv_2
X_3668_ _6943_/Q _3902_/A2 _3826_/B1 _6895_/Q VGND VGND VPWR VPWR _3668_/X sky130_fd_sc_hd__a22o_2
X_6387_ _6578_/A VGND VGND VPWR VPWR _6387_/Y sky130_fd_sc_hd__inv_2
X_5407_ _5407_/A0 _5061_/X _5417_/S VGND VGND VPWR VPWR _7130_/D sky130_fd_sc_hd__mux2_2
X_3599_ _3599_/A _3600_/A VGND VGND VPWR VPWR _4614_/C sky130_fd_sc_hd__nor2_2
XFILLER_0_638 VGND VGND VPWR VPWR sky130_fd_sc_hd__decap_3
XFILLER_102_511 VGND VGND VPWR VPWR sky130_fd_sc_hd__fill_2
XFILLER_102_522 VGND VGND VPWR VPWR sky130_fd_sc_hd__decap_3
X_5338_ _5338_/A0 _5061_/X _5360_/S VGND VGND VPWR VPWR _7162_/D sky130_fd_sc_hd__mux2_2
XFILLER_48_609 VGND VGND VPWR VPWR sky130_fd_sc_hd__decap_3
XFILLER_87_222 VGND VGND VPWR VPWR sky130_fd_sc_hd__fill_2
XFILLER_75_417 VGND VGND VPWR VPWR sky130_fd_sc_hd__decap_3
XFILLER_85_39 VGND VGND VPWR VPWR sky130_fd_sc_hd__fill_1
XFILLER_87_255 VGND VGND VPWR VPWR sky130_fd_sc_hd__decap_3
X_7008_ _7341_/CLK _7008_/D _6288_/Y VGND VGND VPWR VPWR _7008_/Q sky130_fd_sc_hd__dfrtp_2
XTAP_TAPCELL_ROW_89_1318 VGND VPWR sky130_fd_sc_hd__tapvpwrvgnd_1
XFILLER_18_44 VGND VGND VPWR VPWR sky130_fd_sc_hd__decap_3
XFILLER_28_300 VGND VGND VPWR VPWR sky130_fd_sc_hd__decap_3
XFILLER_56_642 VGND VGND VPWR VPWR sky130_fd_sc_hd__fill_2
XFILLER_68_480 VGND VGND VPWR VPWR sky130_fd_sc_hd__decap_3
XFILLER_28_355 VGND VGND VPWR VPWR sky130_fd_sc_hd__decap_3
XFILLER_56_675 VGND VGND VPWR VPWR sky130_fd_sc_hd__decap_3
XFILLER_16_528 VGND VGND VPWR VPWR sky130_fd_sc_hd__decap_3
XFILLER_18_88 VGND VGND VPWR VPWR sky130_fd_sc_hd__decap_3
XFILLER_71_612 VGND VGND VPWR VPWR sky130_fd_sc_hd__decap_3
XFILLER_70_144 VGND VGND VPWR VPWR sky130_fd_sc_hd__decap_3
XFILLER_71_656 VGND VGND VPWR VPWR sky130_fd_sc_hd__decap_3
XFILLER_34_32 VGND VGND VPWR VPWR sky130_fd_sc_hd__decap_3
XTAP_TAPCELL_ROW_54_898 VGND VPWR sky130_fd_sc_hd__tapvpwrvgnd_1
XTAP_TAPCELL_ROW_26_567 VGND VPWR sky130_fd_sc_hd__tapvpwrvgnd_1
XFILLER_11_211 VGND VGND VPWR VPWR sky130_fd_sc_hd__decap_3
XFILLER_11_266 VGND VGND VPWR VPWR sky130_fd_sc_hd__decap_3
XFILLER_11_299 VGND VGND VPWR VPWR sky130_fd_sc_hd__decap_3
XFILLER_7_215 VGND VGND VPWR VPWR sky130_fd_sc_hd__decap_3
XFILLER_50_53 VGND VGND VPWR VPWR sky130_fd_sc_hd__decap_3
XFILLER_50_97 VGND VGND VPWR VPWR sky130_fd_sc_hd__decap_3
XFILLER_3_432 VGND VGND VPWR VPWR sky130_fd_sc_hd__decap_3
XFILLER_98_509 VGND VGND VPWR VPWR sky130_fd_sc_hd__decap_3
XFILLER_59_51 VGND VGND VPWR VPWR sky130_fd_sc_hd__decap_3
XFILLER_78_200 VGND VGND VPWR VPWR sky130_fd_sc_hd__decap_3
XFILLER_105_382 VGND VGND VPWR VPWR sky130_fd_sc_hd__fill_2
XFILLER_105_393 VGND VGND VPWR VPWR sky130_fd_sc_hd__fill_1
XFILLER_22_9 VGND VGND VPWR VPWR sky130_fd_sc_hd__decap_3
XFILLER_66_406 VGND VGND VPWR VPWR sky130_fd_sc_hd__fill_1
XFILLER_78_266 VGND VGND VPWR VPWR sky130_fd_sc_hd__decap_3
XFILLER_115_90 VGND VGND VPWR VPWR sky130_fd_sc_hd__decap_3
XFILLER_47_620 VGND VGND VPWR VPWR sky130_fd_sc_hd__decap_3
XFILLER_78_288 VGND VGND VPWR VPWR sky130_fd_sc_hd__decap_3
XFILLER_93_225 VGND VGND VPWR VPWR sky130_fd_sc_hd__decap_3
XTAP_TAPCELL_ROW_70_1090 VGND VPWR sky130_fd_sc_hd__tapvpwrvgnd_1
XFILLER_19_333 VGND VGND VPWR VPWR sky130_fd_sc_hd__decap_3
XFILLER_19_355 VGND VGND VPWR VPWR sky130_fd_sc_hd__fill_1
XFILLER_46_141 VGND VGND VPWR VPWR sky130_fd_sc_hd__decap_3
XFILLER_47_653 VGND VGND VPWR VPWR sky130_fd_sc_hd__decap_3
XFILLER_75_72 VGND VGND VPWR VPWR sky130_fd_sc_hd__decap_3
XTAP_TAPCELL_ROW_109_1554 VGND VPWR sky130_fd_sc_hd__tapvpwrvgnd_1
XFILLER_19_377 VGND VGND VPWR VPWR sky130_fd_sc_hd__decap_3
XFILLER_46_152 VGND VGND VPWR VPWR sky130_fd_sc_hd__fill_1
XFILLER_46_174 VGND VGND VPWR VPWR sky130_fd_sc_hd__decap_3
XFILLER_62_623 VGND VGND VPWR VPWR sky130_fd_sc_hd__decap_3
XFILLER_74_483 VGND VGND VPWR VPWR sky130_fd_sc_hd__decap_3
XTAP_TAPCELL_ROW_109_1565 VGND VPWR sky130_fd_sc_hd__tapvpwrvgnd_1
XFILLER_34_358 VGND VGND VPWR VPWR sky130_fd_sc_hd__decap_3
XFILLER_61_122 VGND VGND VPWR VPWR sky130_fd_sc_hd__fill_1
XFILLER_62_645 VGND VGND VPWR VPWR sky130_fd_sc_hd__decap_3
XFILLER_15_561 VGND VGND VPWR VPWR sky130_fd_sc_hd__decap_3
XFILLER_22_509 VGND VGND VPWR VPWR sky130_fd_sc_hd__decap_3
XFILLER_62_678 VGND VGND VPWR VPWR sky130_fd_sc_hd__decap_3
XFILLER_30_531 VGND VGND VPWR VPWR sky130_fd_sc_hd__fill_1
XFILLER_61_199 VGND VGND VPWR VPWR sky130_fd_sc_hd__decap_3
XFILLER_91_71 VGND VGND VPWR VPWR sky130_fd_sc_hd__decap_3
X_4640_ _4938_/B _4918_/A VGND VGND VPWR VPWR _4640_/Y sky130_fd_sc_hd__nor2_2
X_6310_ _6634_/A VGND VGND VPWR VPWR _6310_/Y sky130_fd_sc_hd__inv_2
X_4571_ _4571_/A _4577_/B VGND VGND VPWR VPWR _7295_/D sky130_fd_sc_hd__and2_2
XFILLER_115_102 VGND VGND VPWR VPWR sky130_fd_sc_hd__decap_3
X_7290_ _7322_/CLK _7290_/D _6570_/Y VGND VGND VPWR VPWR _7290_/Q sky130_fd_sc_hd__dfrtp_2
Xhold705 _6950_/Q VGND VGND VPWR VPWR _6950_/D sky130_fd_sc_hd__dlygate4sd3_1
Xhold716 _6921_/Q VGND VGND VPWR VPWR _6921_/D sky130_fd_sc_hd__dlygate4sd3_1
Xhold727 _6755_/Q VGND VGND VPWR VPWR _6755_/D sky130_fd_sc_hd__dlygate4sd3_1
X_3522_ _5118_/C _4938_/A _3618_/C VGND VGND VPWR VPWR _3522_/Y sky130_fd_sc_hd__nand3_2
XFILLER_115_146 VGND VGND VPWR VPWR sky130_fd_sc_hd__decap_3
XFILLER_6_292 VGND VGND VPWR VPWR sky130_fd_sc_hd__decap_3
Xhold738 _6771_/Q VGND VGND VPWR VPWR _6771_/D sky130_fd_sc_hd__dlygate4sd3_1
Xhold749 _6852_/Q VGND VGND VPWR VPWR _6852_/D sky130_fd_sc_hd__dlygate4sd3_1
X_3453_ _7218_/Q _4331_/A2 _4332_/B1 _7378_/Q VGND VGND VPWR VPWR _3453_/X sky130_fd_sc_hd__a22o_2
XFILLER_103_319 VGND VGND VPWR VPWR sky130_fd_sc_hd__decap_3
XFILLER_97_520 VGND VGND VPWR VPWR sky130_fd_sc_hd__decap_3
X_3384_ _7315_/Q _3979_/S _4528_/B _7283_/Q VGND VGND VPWR VPWR _3384_/X sky130_fd_sc_hd__a22o_2
XFILLER_111_352 VGND VGND VPWR VPWR sky130_fd_sc_hd__decap_3
XFILLER_69_266 VGND VGND VPWR VPWR sky130_fd_sc_hd__decap_3
XFILLER_29_119 VGND VGND VPWR VPWR sky130_fd_sc_hd__decap_3
XFILLER_84_236 VGND VGND VPWR VPWR sky130_fd_sc_hd__decap_3
X_5054_ _5054_/A VGND VGND VPWR VPWR _5054_/Y sky130_fd_sc_hd__inv_2
XFILLER_37_152 VGND VGND VPWR VPWR sky130_fd_sc_hd__decap_3
XFILLER_38_686 VGND VGND VPWR VPWR sky130_fd_sc_hd__decap_3
XFILLER_53_601 VGND VGND VPWR VPWR sky130_fd_sc_hd__decap_3
XFILLER_53_623 VGND VGND VPWR VPWR sky130_fd_sc_hd__decap_3
XFILLER_111_37 VGND VGND VPWR VPWR sky130_fd_sc_hd__decap_3
XFILLER_25_358 VGND VGND VPWR VPWR sky130_fd_sc_hd__decap_3
XFILLER_37_196 VGND VGND VPWR VPWR sky130_fd_sc_hd__decap_3
XFILLER_53_667 VGND VGND VPWR VPWR sky130_fd_sc_hd__decap_3
XTAP_TAPCELL_ROW_84_1259 VGND VPWR sky130_fd_sc_hd__tapvpwrvgnd_1
XFILLER_52_144 VGND VGND VPWR VPWR sky130_fd_sc_hd__decap_3
XFILLER_52_177 VGND VGND VPWR VPWR sky130_fd_sc_hd__decap_3
XFILLER_80_475 VGND VGND VPWR VPWR sky130_fd_sc_hd__fill_1
X_4907_ _4948_/A _4888_/B _4903_/X _4906_/X VGND VGND VPWR VPWR _5657_/B sky130_fd_sc_hd__o31ai_4
XTAP_TAPCELL_ROW_23_526 VGND VPWR sky130_fd_sc_hd__tapvpwrvgnd_1
XTAP_TAPCELL_ROW_51_868 VGND VPWR sky130_fd_sc_hd__tapvpwrvgnd_1
XFILLER_21_597 VGND VGND VPWR VPWR sky130_fd_sc_hd__decap_3
X_4769_ _4969_/B _4741_/X _4761_/Y _4768_/Y VGND VGND VPWR VPWR _5663_/A sky130_fd_sc_hd__a31o_2
XFILLER_107_647 VGND VGND VPWR VPWR sky130_fd_sc_hd__decap_3
XFILLER_20_12 VGND VGND VPWR VPWR sky130_fd_sc_hd__decap_3
XFILLER_4_218 VGND VGND VPWR VPWR sky130_fd_sc_hd__decap_3
X_6508_ _6608_/A VGND VGND VPWR VPWR _6508_/Y sky130_fd_sc_hd__inv_2
XFILLER_105_6 VGND VGND VPWR VPWR sky130_fd_sc_hd__decap_3
XFILLER_106_157 VGND VGND VPWR VPWR sky130_fd_sc_hd__decap_3
X_6439_ _6532_/A VGND VGND VPWR VPWR _6439_/Y sky130_fd_sc_hd__inv_2
XTAP_TAPCELL_ROW_95_1388 VGND VPWR sky130_fd_sc_hd__tapvpwrvgnd_1
XFILLER_0_402 VGND VGND VPWR VPWR sky130_fd_sc_hd__decap_3
XFILLER_0_424 VGND VGND VPWR VPWR sky130_fd_sc_hd__decap_3
XFILLER_0_446 VGND VGND VPWR VPWR sky130_fd_sc_hd__fill_2
XFILLER_96_38 VGND VGND VPWR VPWR sky130_fd_sc_hd__decap_3
XFILLER_102_341 VGND VGND VPWR VPWR sky130_fd_sc_hd__fill_2
XFILLER_102_363 VGND VGND VPWR VPWR sky130_fd_sc_hd__fill_1
XFILLER_29_21 VGND VGND VPWR VPWR sky130_fd_sc_hd__decap_3
XFILLER_75_203 VGND VGND VPWR VPWR sky130_fd_sc_hd__decap_3
XFILLER_88_564 VGND VGND VPWR VPWR sky130_fd_sc_hd__decap_3
XFILLER_102_374 VGND VGND VPWR VPWR sky130_fd_sc_hd__decap_3
XFILLER_29_87 VGND VGND VPWR VPWR sky130_fd_sc_hd__decap_3
XFILLER_75_225 VGND VGND VPWR VPWR sky130_fd_sc_hd__decap_3
XFILLER_28_141 VGND VGND VPWR VPWR sky130_fd_sc_hd__decap_3
XFILLER_29_642 VGND VGND VPWR VPWR sky130_fd_sc_hd__decap_3
XTAP_TAPCELL_ROW_59_957 VGND VPWR sky130_fd_sc_hd__tapvpwrvgnd_1
XFILLER_16_303 VGND VGND VPWR VPWR sky130_fd_sc_hd__fill_1
XFILLER_56_472 VGND VGND VPWR VPWR sky130_fd_sc_hd__decap_3
Xplace409 _4429_/B1 VGND VGND VPWR VPWR _4437_/B1 sky130_fd_sc_hd__buf_2
XTAP_TAPCELL_ROW_3_284 VGND VPWR sky130_fd_sc_hd__tapvpwrvgnd_1
XPHY_EDGE_ROW_11_Left_128 VGND VGND VPWR VPWR sky130_fd_sc_hd__decap_3
XFILLER_44_645 VGND VGND VPWR VPWR sky130_fd_sc_hd__decap_3
XFILLER_45_42 VGND VGND VPWR VPWR sky130_fd_sc_hd__decap_3
XFILLER_71_442 VGND VGND VPWR VPWR sky130_fd_sc_hd__decap_3
XFILLER_90_239 VGND VGND VPWR VPWR sky130_fd_sc_hd__decap_3
XFILLER_44_678 VGND VGND VPWR VPWR sky130_fd_sc_hd__decap_3
XFILLER_71_475 VGND VGND VPWR VPWR sky130_fd_sc_hd__decap_3
XFILLER_61_52 VGND VGND VPWR VPWR sky130_fd_sc_hd__decap_3
XTAP_TAPCELL_ROW_104_1495 VGND VPWR sky130_fd_sc_hd__tapvpwrvgnd_1
XFILLER_61_63 VGND VGND VPWR VPWR sky130_fd_sc_hd__decap_3
XANTENNA_7 _4393_/X VGND VGND VPWR VPWR sky130_fd_sc_hd__diode_2
XFILLER_6_47 VGND VGND VPWR VPWR sky130_fd_sc_hd__decap_3
XPHY_EDGE_ROW_20_Left_137 VGND VGND VPWR VPWR sky130_fd_sc_hd__decap_3
XFILLER_113_606 VGND VGND VPWR VPWR sky130_fd_sc_hd__decap_3
XFILLER_113_617 VGND VGND VPWR VPWR sky130_fd_sc_hd__decap_3
XFILLER_98_339 VGND VGND VPWR VPWR sky130_fd_sc_hd__decap_3
XFILLER_98_306 VGND VGND VPWR VPWR sky130_fd_sc_hd__fill_2
XFILLER_112_127 VGND VGND VPWR VPWR sky130_fd_sc_hd__decap_3
XFILLER_3_273 VGND VGND VPWR VPWR sky130_fd_sc_hd__decap_3
XFILLER_79_520 VGND VGND VPWR VPWR sky130_fd_sc_hd__fill_2
XFILLER_79_531 VGND VGND VPWR VPWR sky130_fd_sc_hd__decap_3
XFILLER_20_6 VGND VGND VPWR VPWR sky130_fd_sc_hd__decap_3
XFILLER_86_82 VGND VGND VPWR VPWR sky130_fd_sc_hd__fill_2
XFILLER_94_578 VGND VGND VPWR VPWR sky130_fd_sc_hd__decap_3
XFILLER_34_100 VGND VGND VPWR VPWR sky130_fd_sc_hd__decap_3
XFILLER_19_196 VGND VGND VPWR VPWR sky130_fd_sc_hd__decap_3
XFILLER_35_645 VGND VGND VPWR VPWR sky130_fd_sc_hd__decap_3
XFILLER_62_442 VGND VGND VPWR VPWR sky130_fd_sc_hd__decap_3
XFILLER_74_280 VGND VGND VPWR VPWR sky130_fd_sc_hd__decap_3
XFILLER_74_291 VGND VGND VPWR VPWR sky130_fd_sc_hd__decap_3
XFILLER_34_144 VGND VGND VPWR VPWR sky130_fd_sc_hd__decap_3
XFILLER_35_667 VGND VGND VPWR VPWR sky130_fd_sc_hd__decap_3
XFILLER_50_615 VGND VGND VPWR VPWR sky130_fd_sc_hd__decap_3
X_6790_ _6931_/CLK _6790_/D VGND VGND VPWR VPWR _6790_/Q sky130_fd_sc_hd__dfxtp_2
XFILLER_15_380 VGND VGND VPWR VPWR sky130_fd_sc_hd__decap_3
XFILLER_34_177 VGND VGND VPWR VPWR sky130_fd_sc_hd__decap_3
XFILLER_50_648 VGND VGND VPWR VPWR sky130_fd_sc_hd__decap_3
XFILLER_62_486 VGND VGND VPWR VPWR sky130_fd_sc_hd__decap_3
X_4623_ _4330_/B _4622_/X _5057_/B VGND VGND VPWR VPWR _4624_/A sky130_fd_sc_hd__o21ba_2
X_7342_ _7403_/CLK _7342_/D _6622_/Y VGND VGND VPWR VPWR _7342_/Q sky130_fd_sc_hd__dfrtp_2
X_4554_ _4554_/A _4567_/B VGND VGND VPWR VPWR _7303_/D sky130_fd_sc_hd__and2_2
XFILLER_116_455 VGND VGND VPWR VPWR sky130_fd_sc_hd__decap_3
X_7273_ _7338_/CLK _7273_/D _6553_/Y VGND VGND VPWR VPWR _7273_/Q sky130_fd_sc_hd__dfrtp_2
X_3505_ _3505_/A _3505_/B VGND VGND VPWR VPWR _3505_/X sky130_fd_sc_hd__or2_4
XFILLER_116_477 VGND VGND VPWR VPWR sky130_fd_sc_hd__decap_3
XFILLER_89_306 VGND VGND VPWR VPWR sky130_fd_sc_hd__decap_3
XFILLER_103_138 VGND VGND VPWR VPWR sky130_fd_sc_hd__decap_3
XFILLER_106_15 VGND VGND VPWR VPWR sky130_fd_sc_hd__decap_3
XFILLER_106_59 VGND VGND VPWR VPWR sky130_fd_sc_hd__decap_3
XFILLER_112_672 VGND VGND VPWR VPWR sky130_fd_sc_hd__decap_3
XFILLER_85_512 VGND VGND VPWR VPWR sky130_fd_sc_hd__decap_3
Xhold1202 _7153_/Q VGND VGND VPWR VPWR _5356_/A0 sky130_fd_sc_hd__dlygate4sd3_1
Xhold1213 _7343_/Q VGND VGND VPWR VPWR _4471_/A0 sky130_fd_sc_hd__dlygate4sd3_1
X_5106_ _6985_/Q _5068_/C _5581_/S VGND VGND VPWR VPWR _5106_/X sky130_fd_sc_hd__o21a_2
XFILLER_45_409 VGND VGND VPWR VPWR sky130_fd_sc_hd__fill_2
XFILLER_85_567 VGND VGND VPWR VPWR sky130_fd_sc_hd__decap_3
X_5037_ _6988_/Q _5045_/B VGND VGND VPWR VPWR _5038_/B sky130_fd_sc_hd__nand2_2
XFILLER_38_461 VGND VGND VPWR VPWR sky130_fd_sc_hd__decap_3
XFILLER_72_217 VGND VGND VPWR VPWR sky130_fd_sc_hd__decap_3
XTAP_TAPCELL_ROW_56_927 VGND VPWR sky130_fd_sc_hd__tapvpwrvgnd_1
XFILLER_25_111 VGND VGND VPWR VPWR sky130_fd_sc_hd__fill_1
XFILLER_53_420 VGND VGND VPWR VPWR sky130_fd_sc_hd__decap_3
XFILLER_82_29 VGND VGND VPWR VPWR sky130_fd_sc_hd__decap_3
XTAP_TAPCELL_ROW_0_254 VGND VPWR sky130_fd_sc_hd__tapvpwrvgnd_1
XTAP_TAPCELL_ROW_0_243 VGND VPWR sky130_fd_sc_hd__tapvpwrvgnd_1
XFILLER_13_306 VGND VGND VPWR VPWR sky130_fd_sc_hd__decap_3
XFILLER_15_12 VGND VGND VPWR VPWR sky130_fd_sc_hd__decap_3
XFILLER_41_615 VGND VGND VPWR VPWR sky130_fd_sc_hd__fill_1
XFILLER_15_45 VGND VGND VPWR VPWR sky130_fd_sc_hd__decap_3
XFILLER_25_188 VGND VGND VPWR VPWR sky130_fd_sc_hd__decap_3
XFILLER_40_103 VGND VGND VPWR VPWR sky130_fd_sc_hd__decap_3
X_6988_ _7401_/CLK _6988_/D _6268_/Y VGND VGND VPWR VPWR _6988_/Q sky130_fd_sc_hd__dfrtp_2
XTAP_TAPCELL_ROW_36_684 VGND VPWR sky130_fd_sc_hd__tapvpwrvgnd_1
XFILLER_15_78 VGND VGND VPWR VPWR sky130_fd_sc_hd__decap_3
XFILLER_41_659 VGND VGND VPWR VPWR sky130_fd_sc_hd__decap_3
XFILLER_21_350 VGND VGND VPWR VPWR sky130_fd_sc_hd__decap_3
XTAP_TAPCELL_ROW_97_1417 VGND VPWR sky130_fd_sc_hd__tapvpwrvgnd_1
XFILLER_31_66 VGND VGND VPWR VPWR sky130_fd_sc_hd__fill_1
XFILLER_103_3 VGND VGND VPWR VPWR sky130_fd_sc_hd__decap_3
XTAP_TAPCELL_ROW_8_343 VGND VPWR sky130_fd_sc_hd__tapvpwrvgnd_1
XFILLER_0_243 VGND VGND VPWR VPWR sky130_fd_sc_hd__fill_1
XFILLER_88_350 VGND VGND VPWR VPWR sky130_fd_sc_hd__fill_1
XFILLER_0_265 VGND VGND VPWR VPWR sky130_fd_sc_hd__decap_3
XFILLER_48_203 VGND VGND VPWR VPWR sky130_fd_sc_hd__fill_2
XFILLER_76_545 VGND VGND VPWR VPWR sky130_fd_sc_hd__decap_3
XFILLER_76_578 VGND VGND VPWR VPWR sky130_fd_sc_hd__fill_2
XFILLER_17_612 VGND VGND VPWR VPWR sky130_fd_sc_hd__decap_3
XFILLER_63_206 VGND VGND VPWR VPWR sky130_fd_sc_hd__decap_3
XFILLER_16_100 VGND VGND VPWR VPWR sky130_fd_sc_hd__fill_1
XFILLER_17_623 VGND VGND VPWR VPWR sky130_fd_sc_hd__fill_2
XFILLER_17_634 VGND VGND VPWR VPWR sky130_fd_sc_hd__fill_1
XFILLER_29_483 VGND VGND VPWR VPWR sky130_fd_sc_hd__decap_3
XFILLER_44_431 VGND VGND VPWR VPWR sky130_fd_sc_hd__decap_3
XFILLER_56_85 VGND VGND VPWR VPWR sky130_fd_sc_hd__decap_3
XTAP_TAPCELL_ROW_106_1524 VGND VPWR sky130_fd_sc_hd__tapvpwrvgnd_1
XFILLER_16_144 VGND VGND VPWR VPWR sky130_fd_sc_hd__decap_3
XFILLER_112_80 VGND VGND VPWR VPWR sky130_fd_sc_hd__decap_3
XFILLER_112_91 VGND VGND VPWR VPWR sky130_fd_sc_hd__decap_3
XFILLER_31_125 VGND VGND VPWR VPWR sky130_fd_sc_hd__decap_3
XFILLER_44_486 VGND VGND VPWR VPWR sky130_fd_sc_hd__fill_1
XFILLER_72_51 VGND VGND VPWR VPWR sky130_fd_sc_hd__decap_3
XFILLER_31_158 VGND VGND VPWR VPWR sky130_fd_sc_hd__decap_3
XFILLER_12_372 VGND VGND VPWR VPWR sky130_fd_sc_hd__fill_2
XFILLER_31_169 VGND VGND VPWR VPWR sky130_fd_sc_hd__fill_2
XFILLER_12_394 VGND VGND VPWR VPWR sky130_fd_sc_hd__decap_3
XFILLER_8_365 VGND VGND VPWR VPWR sky130_fd_sc_hd__decap_3
XFILLER_113_425 VGND VGND VPWR VPWR sky130_fd_sc_hd__decap_3
X_4270_ _7358_/Q _4272_/B VGND VGND VPWR VPWR _4270_/Y sky130_fd_sc_hd__nand2_2
XFILLER_99_659 VGND VGND VPWR VPWR sky130_fd_sc_hd__decap_3
XFILLER_98_114 VGND VGND VPWR VPWR sky130_fd_sc_hd__decap_3
XFILLER_101_609 VGND VGND VPWR VPWR sky130_fd_sc_hd__decap_3
XFILLER_67_501 VGND VGND VPWR VPWR sky130_fd_sc_hd__decap_3
XFILLER_86_309 VGND VGND VPWR VPWR sky130_fd_sc_hd__decap_3
XFILLER_97_92 VGND VGND VPWR VPWR sky130_fd_sc_hd__decap_3
XFILLER_97_70 VGND VGND VPWR VPWR sky130_fd_sc_hd__decap_3
XFILLER_39_203 VGND VGND VPWR VPWR sky130_fd_sc_hd__decap_3
XFILLER_39_225 VGND VGND VPWR VPWR sky130_fd_sc_hd__decap_3
XFILLER_79_383 VGND VGND VPWR VPWR sky130_fd_sc_hd__decap_3
XFILLER_39_258 VGND VGND VPWR VPWR sky130_fd_sc_hd__decap_3
XFILLER_67_567 VGND VGND VPWR VPWR sky130_fd_sc_hd__decap_3
XFILLER_94_342 VGND VGND VPWR VPWR sky130_fd_sc_hd__decap_3
XFILLER_67_589 VGND VGND VPWR VPWR sky130_fd_sc_hd__decap_3
XFILLER_82_504 VGND VGND VPWR VPWR sky130_fd_sc_hd__decap_3
XFILLER_94_397 VGND VGND VPWR VPWR sky130_fd_sc_hd__fill_2
X_6911_ _6911_/CLK _6911_/D VGND VGND VPWR VPWR _6911_/Q sky130_fd_sc_hd__dfxtp_2
XFILLER_35_464 VGND VGND VPWR VPWR sky130_fd_sc_hd__decap_3
X_6842_ _6972_/CLK _6842_/D VGND VGND VPWR VPWR _6842_/Q sky130_fd_sc_hd__dfxtp_2
XFILLER_22_103 VGND VGND VPWR VPWR sky130_fd_sc_hd__decap_3
XFILLER_90_592 VGND VGND VPWR VPWR sky130_fd_sc_hd__decap_3
XTAP_TAPCELL_ROW_81_1229 VGND VPWR sky130_fd_sc_hd__tapvpwrvgnd_1
XTAP_TAPCELL_ROW_81_1218 VGND VPWR sky130_fd_sc_hd__tapvpwrvgnd_1
XFILLER_22_136 VGND VGND VPWR VPWR sky130_fd_sc_hd__decap_3
XFILLER_22_147 VGND VGND VPWR VPWR sky130_fd_sc_hd__decap_3
XFILLER_22_158 VGND VGND VPWR VPWR sky130_fd_sc_hd__decap_3
XFILLER_62_294 VGND VGND VPWR VPWR sky130_fd_sc_hd__decap_3
X_6773_ _6977_/CLK _6773_/D VGND VGND VPWR VPWR _6773_/Q sky130_fd_sc_hd__dfxtp_2
X_3985_ _7348_/Q _4526_/A0 _3989_/S VGND VGND VPWR VPWR _7348_/D sky130_fd_sc_hd__mux2_2
XTAP_TAPCELL_ROW_33_643 VGND VPWR sky130_fd_sc_hd__tapvpwrvgnd_1
XFILLER_10_309 VGND VGND VPWR VPWR sky130_fd_sc_hd__decap_3
XTAP_TAPCELL_ROW_61_985 VGND VPWR sky130_fd_sc_hd__tapvpwrvgnd_1
XFILLER_30_191 VGND VGND VPWR VPWR sky130_fd_sc_hd__decap_3
X_5655_ _5655_/A _5655_/B _5655_/C _5655_/D VGND VGND VPWR VPWR _5665_/B sky130_fd_sc_hd__nor4_2
X_4606_ _5666_/A _5633_/B VGND VGND VPWR VPWR _4606_/Y sky130_fd_sc_hd__nor2_2
XFILLER_7_90 VGND VGND VPWR VPWR sky130_fd_sc_hd__decap_3
X_7325_ _7356_/CLK _7325_/D _6605_/Y VGND VGND VPWR VPWR _7325_/Q sky130_fd_sc_hd__dfrtp_2
X_5586_ hold966/X _5595_/B _5118_/X VGND VGND VPWR VPWR _7035_/D sky130_fd_sc_hd__o21a_2
XFILLER_104_414 VGND VGND VPWR VPWR sky130_fd_sc_hd__decap_3
X_4537_ _5118_/A _4537_/B _4537_/C VGND VGND VPWR VPWR _4577_/B sky130_fd_sc_hd__or3_2
XFILLER_77_18 VGND VGND VPWR VPWR sky130_fd_sc_hd__decap_3
X_7256_ clkload9/A _7256_/D _6536_/Y VGND VGND VPWR VPWR _7256_/Q sky130_fd_sc_hd__dfrtp_2
X_4468_ _7009_/Q _5152_/B _5595_/B VGND VGND VPWR VPWR _4468_/X sky130_fd_sc_hd__o21a_2
XTAP_TAPCELL_ROW_92_1358 VGND VPWR sky130_fd_sc_hd__tapvpwrvgnd_1
XFILLER_77_309 VGND VGND VPWR VPWR sky130_fd_sc_hd__fill_2
X_7187_ clkload4/A _7187_/D _6467_/Y VGND VGND VPWR VPWR _7187_/Q sky130_fd_sc_hd__dfrtp_2
X_3419_ _7123_/Q _3407_/X _3413_/X _3418_/X VGND VGND VPWR VPWR _3419_/Y sky130_fd_sc_hd__a211oi_2
XTAP_TAPCELL_ROW_5_313 VGND VPWR sky130_fd_sc_hd__tapvpwrvgnd_1
XFILLER_112_480 VGND VGND VPWR VPWR sky130_fd_sc_hd__decap_3
X_4399_ _7370_/Q _4429_/B1 _4398_/X _4429_/C1 VGND VGND VPWR VPWR _4399_/X sky130_fd_sc_hd__a211o_2
XFILLER_98_681 VGND VGND VPWR VPWR sky130_fd_sc_hd__decap_3
XFILLER_100_642 VGND VGND VPWR VPWR sky130_fd_sc_hd__fill_2
XFILLER_97_180 VGND VGND VPWR VPWR sky130_fd_sc_hd__fill_1
Xhold1010 _7244_/Q VGND VGND VPWR VPWR _5167_/A sky130_fd_sc_hd__dlygate4sd3_1
Xhold1021 _7386_/Q VGND VGND VPWR VPWR _3860_/A0 sky130_fd_sc_hd__dlygate4sd3_1
Xhold1032 _7194_/Q VGND VGND VPWR VPWR _5272_/A0 sky130_fd_sc_hd__dlygate4sd3_1
XFILLER_100_675 VGND VGND VPWR VPWR sky130_fd_sc_hd__decap_3
XFILLER_73_515 VGND VGND VPWR VPWR sky130_fd_sc_hd__decap_3
XFILLER_93_39 VGND VGND VPWR VPWR sky130_fd_sc_hd__decap_3
Xhold1043 _7242_/Q VGND VGND VPWR VPWR _5171_/A sky130_fd_sc_hd__dlygate4sd3_1
Xhold1054 _7395_/Q VGND VGND VPWR VPWR _3763_/A1 sky130_fd_sc_hd__dlygate4sd3_1
Xhold1065 _7277_/Q VGND VGND VPWR VPWR _4735_/A0 sky130_fd_sc_hd__dlygate4sd3_1
Xhold1076 _7240_/Q VGND VGND VPWR VPWR _5175_/A sky130_fd_sc_hd__dlygate4sd3_1
XFILLER_45_228 VGND VGND VPWR VPWR sky130_fd_sc_hd__decap_3
XFILLER_73_548 VGND VGND VPWR VPWR sky130_fd_sc_hd__decap_3
Xhold1087 _7233_/Q VGND VGND VPWR VPWR _5190_/A sky130_fd_sc_hd__dlygate4sd3_1
Xhold1098 _7301_/Q VGND VGND VPWR VPWR _4559_/A sky130_fd_sc_hd__dlygate4sd3_1
XFILLER_26_55 VGND VGND VPWR VPWR sky130_fd_sc_hd__decap_3
XFILLER_26_88 VGND VGND VPWR VPWR sky130_fd_sc_hd__decap_3
XFILLER_53_261 VGND VGND VPWR VPWR sky130_fd_sc_hd__decap_3
XFILLER_53_294 VGND VGND VPWR VPWR sky130_fd_sc_hd__decap_3
XFILLER_9_107 VGND VGND VPWR VPWR sky130_fd_sc_hd__decap_3
XFILLER_13_169 VGND VGND VPWR VPWR sky130_fd_sc_hd__decap_3
XFILLER_42_21 VGND VGND VPWR VPWR sky130_fd_sc_hd__decap_3
XFILLER_42_43 VGND VGND VPWR VPWR sky130_fd_sc_hd__decap_3
XTAP_TAPCELL_ROW_101_1465 VGND VPWR sky130_fd_sc_hd__tapvpwrvgnd_1
XFILLER_110_406 VGND VGND VPWR VPWR sky130_fd_sc_hd__decap_3
XFILLER_3_15 VGND VGND VPWR VPWR sky130_fd_sc_hd__decap_3
XFILLER_68_309 VGND VGND VPWR VPWR sky130_fd_sc_hd__fill_2
XFILLER_110_417 VGND VGND VPWR VPWR sky130_fd_sc_hd__decap_3
XFILLER_3_48 VGND VGND VPWR VPWR sky130_fd_sc_hd__decap_3
XFILLER_67_51 VGND VGND VPWR VPWR sky130_fd_sc_hd__decap_3
XTAP_TAPCELL_ROW_112_1594 VGND VPWR sky130_fd_sc_hd__tapvpwrvgnd_1
XFILLER_103_491 VGND VGND VPWR VPWR sky130_fd_sc_hd__decap_3
XFILLER_88_180 VGND VGND VPWR VPWR sky130_fd_sc_hd__decap_3
XFILLER_36_206 VGND VGND VPWR VPWR sky130_fd_sc_hd__decap_3
XFILLER_49_578 VGND VGND VPWR VPWR sky130_fd_sc_hd__fill_1
XFILLER_64_504 VGND VGND VPWR VPWR sky130_fd_sc_hd__decap_3
XFILLER_64_526 VGND VGND VPWR VPWR sky130_fd_sc_hd__decap_3
XFILLER_91_345 VGND VGND VPWR VPWR sky130_fd_sc_hd__fill_1
XFILLER_91_367 VGND VGND VPWR VPWR sky130_fd_sc_hd__fill_1
XTAP_TAPCELL_ROW_67_1051 VGND VPWR sky130_fd_sc_hd__tapvpwrvgnd_1
XPHY_EDGE_ROW_103_Left_220 VGND VGND VPWR VPWR sky130_fd_sc_hd__decap_3
XFILLER_32_401 VGND VGND VPWR VPWR sky130_fd_sc_hd__decap_3
XFILLER_83_72 VGND VGND VPWR VPWR sky130_fd_sc_hd__fill_1
XFILLER_83_83 VGND VGND VPWR VPWR sky130_fd_sc_hd__decap_3
X_3770_ _3770_/A1 _4466_/A _4944_/B VGND VGND VPWR VPWR _7393_/D sky130_fd_sc_hd__a21o_2
XTAP_TAPCELL_ROW_30_613 VGND VPWR sky130_fd_sc_hd__tapvpwrvgnd_1
XFILLER_66_3 VGND VGND VPWR VPWR sky130_fd_sc_hd__decap_3
XTAP_TAPCELL_ROW_10_370 VGND VPWR sky130_fd_sc_hd__tapvpwrvgnd_1
X_5371_ _5371_/A0 _4771_/X _5383_/S VGND VGND VPWR VPWR _7147_/D sky130_fd_sc_hd__mux2_2
XFILLER_113_211 VGND VGND VPWR VPWR sky130_fd_sc_hd__decap_3
X_7110_ _7368_/CLK _7110_/D _6390_/Y VGND VGND VPWR VPWR _7110_/Q sky130_fd_sc_hd__dfrtp_2
X_4322_ _7290_/Q _5080_/S _4352_/B1 _7162_/Q _4321_/X VGND VGND VPWR VPWR _4322_/X
+ sky130_fd_sc_hd__a221o_2
XTAP_TAPCELL_ROW_78_1191 VGND VPWR sky130_fd_sc_hd__tapvpwrvgnd_1
XFILLER_99_434 VGND VGND VPWR VPWR sky130_fd_sc_hd__decap_3
XFILLER_113_255 VGND VGND VPWR VPWR sky130_fd_sc_hd__fill_1
X_7041_ _7392_/CLK _7041_/D _6321_/Y VGND VGND VPWR VPWR _7041_/Q sky130_fd_sc_hd__dfrtp_2
X_4253_ _7389_/Q _4346_/B1 _5080_/S _7293_/Q _4252_/X VGND VGND VPWR VPWR _4253_/X
+ sky130_fd_sc_hd__a221o_2
XFILLER_101_417 VGND VGND VPWR VPWR sky130_fd_sc_hd__decap_3
XFILLER_113_299 VGND VGND VPWR VPWR sky130_fd_sc_hd__decap_3
XFILLER_87_629 VGND VGND VPWR VPWR sky130_fd_sc_hd__decap_3
XFILLER_99_489 VGND VGND VPWR VPWR sky130_fd_sc_hd__decap_3
X_4184_ _7296_/Q _5028_/S _4351_/A2 _7104_/Q _4183_/X VGND VGND VPWR VPWR _4185_/C
+ sky130_fd_sc_hd__a221o_2
XFILLER_27_206 VGND VGND VPWR VPWR sky130_fd_sc_hd__decap_3
XFILLER_94_161 VGND VGND VPWR VPWR sky130_fd_sc_hd__decap_3
XFILLER_95_662 VGND VGND VPWR VPWR sky130_fd_sc_hd__decap_3
XFILLER_95_673 VGND VGND VPWR VPWR sky130_fd_sc_hd__decap_3
XTAP_TAPCELL_ROW_38_713 VGND VPWR sky130_fd_sc_hd__tapvpwrvgnd_1
XTAP_TAPCELL_ROW_38_702 VGND VPWR sky130_fd_sc_hd__tapvpwrvgnd_1
XFILLER_103_27 VGND VGND VPWR VPWR sky130_fd_sc_hd__decap_3
XFILLER_27_228 VGND VGND VPWR VPWR sky130_fd_sc_hd__decap_3
XFILLER_82_312 VGND VGND VPWR VPWR sky130_fd_sc_hd__decap_3
XFILLER_82_345 VGND VGND VPWR VPWR sky130_fd_sc_hd__decap_3
XFILLER_35_250 VGND VGND VPWR VPWR sky130_fd_sc_hd__decap_3
XFILLER_82_389 VGND VGND VPWR VPWR sky130_fd_sc_hd__decap_3
XTAP_TAPCELL_ROW_18_470 VGND VPWR sky130_fd_sc_hd__tapvpwrvgnd_1
X_6825_ _6972_/CLK _6825_/D VGND VGND VPWR VPWR _6825_/Q sky130_fd_sc_hd__dfxtp_2
XFILLER_11_629 VGND VGND VPWR VPWR sky130_fd_sc_hd__fill_2
X_6756_ _6911_/CLK _6756_/D VGND VGND VPWR VPWR _6756_/Q sky130_fd_sc_hd__dfxtp_2
X_3968_ _7356_/Q _7324_/Q _3968_/S VGND VGND VPWR VPWR _7356_/D sky130_fd_sc_hd__mux2_2
XFILLER_10_117 VGND VGND VPWR VPWR sky130_fd_sc_hd__decap_3
XFILLER_12_24 VGND VGND VPWR VPWR sky130_fd_sc_hd__decap_3
XFILLER_12_35 VGND VGND VPWR VPWR sky130_fd_sc_hd__decap_3
X_6687_ _7387_/CLK _6687_/D VGND VGND VPWR VPWR _6687_/Q sky130_fd_sc_hd__dfxtp_2
X_3899_ _6693_/Q _3925_/A2 _3917_/B1 _6871_/Q _3746_/C VGND VGND VPWR VPWR _3899_/X
+ sky130_fd_sc_hd__a221o_2
X_5569_ _5569_/A1 _4909_/A _4910_/B VGND VGND VPWR VPWR _7048_/D sky130_fd_sc_hd__a21bo_2
XFILLER_104_200 VGND VGND VPWR VPWR sky130_fd_sc_hd__decap_3
XFILLER_2_327 VGND VGND VPWR VPWR sky130_fd_sc_hd__fill_1
X_7308_ _7341_/CLK _7308_/D _6588_/Y VGND VGND VPWR VPWR _7308_/Q sky130_fd_sc_hd__dfrtp_2
X_7239_ _7369_/CLK _7239_/D _6519_/Y VGND VGND VPWR VPWR _7239_/Q sky130_fd_sc_hd__dfrtp_2
XFILLER_104_299 VGND VGND VPWR VPWR sky130_fd_sc_hd__decap_3
XFILLER_86_651 VGND VGND VPWR VPWR sky130_fd_sc_hd__decap_3
XFILLER_100_461 VGND VGND VPWR VPWR sky130_fd_sc_hd__decap_3
XFILLER_37_21 VGND VGND VPWR VPWR sky130_fd_sc_hd__decap_3
XFILLER_58_353 VGND VGND VPWR VPWR sky130_fd_sc_hd__decap_3
XFILLER_85_161 VGND VGND VPWR VPWR sky130_fd_sc_hd__fill_2
XFILLER_86_662 VGND VGND VPWR VPWR sky130_fd_sc_hd__decap_3
XFILLER_100_483 VGND VGND VPWR VPWR sky130_fd_sc_hd__decap_3
XFILLER_18_239 VGND VGND VPWR VPWR sky130_fd_sc_hd__decap_3
XFILLER_37_87 VGND VGND VPWR VPWR sky130_fd_sc_hd__decap_3
XFILLER_26_283 VGND VGND VPWR VPWR sky130_fd_sc_hd__decap_3
XFILLER_41_231 VGND VGND VPWR VPWR sky130_fd_sc_hd__decap_3
XFILLER_53_42 VGND VGND VPWR VPWR sky130_fd_sc_hd__decap_3
XFILLER_54_592 VGND VGND VPWR VPWR sky130_fd_sc_hd__decap_3
XFILLER_41_264 VGND VGND VPWR VPWR sky130_fd_sc_hd__fill_2
XFILLER_6_600 VGND VGND VPWR VPWR sky130_fd_sc_hd__decap_3
XFILLER_52_9 VGND VGND VPWR VPWR sky130_fd_sc_hd__fill_1
XFILLER_5_154 VGND VGND VPWR VPWR sky130_fd_sc_hd__decap_3
XFILLER_6_666 VGND VGND VPWR VPWR sky130_fd_sc_hd__decap_3
XFILLER_108_583 VGND VGND VPWR VPWR sky130_fd_sc_hd__decap_3
XTAP_TAPCELL_ROW_114_1623 VGND VPWR sky130_fd_sc_hd__tapvpwrvgnd_1
XFILLER_78_50 VGND VGND VPWR VPWR sky130_fd_sc_hd__decap_3
XFILLER_110_203 VGND VGND VPWR VPWR sky130_fd_sc_hd__decap_3
XFILLER_78_61 VGND VGND VPWR VPWR sky130_fd_sc_hd__decap_3
XFILLER_78_94 VGND VGND VPWR VPWR sky130_fd_sc_hd__decap_3
XFILLER_96_415 VGND VGND VPWR VPWR sky130_fd_sc_hd__decap_3
XFILLER_1_393 VGND VGND VPWR VPWR sky130_fd_sc_hd__decap_3
XFILLER_68_139 VGND VGND VPWR VPWR sky130_fd_sc_hd__fill_1
XFILLER_76_150 VGND VGND VPWR VPWR sky130_fd_sc_hd__decap_3
XFILLER_77_673 VGND VGND VPWR VPWR sky130_fd_sc_hd__decap_3
XFILLER_64_312 VGND VGND VPWR VPWR sky130_fd_sc_hd__decap_3
XFILLER_76_172 VGND VGND VPWR VPWR sky130_fd_sc_hd__decap_3
XFILLER_92_643 VGND VGND VPWR VPWR sky130_fd_sc_hd__fill_1
XFILLER_52_507 VGND VGND VPWR VPWR sky130_fd_sc_hd__decap_3
XFILLER_92_654 VGND VGND VPWR VPWR sky130_fd_sc_hd__decap_3
XFILLER_94_82 VGND VGND VPWR VPWR sky130_fd_sc_hd__fill_2
XFILLER_17_261 VGND VGND VPWR VPWR sky130_fd_sc_hd__decap_3
XFILLER_92_687 VGND VGND VPWR VPWR sky130_fd_sc_hd__decap_3
X_4940_ _4814_/A _4937_/Y _4939_/X VGND VGND VPWR VPWR _4940_/Y sky130_fd_sc_hd__o21ai_2
X_4871_ _4845_/A _4643_/Y _4841_/Y _4948_/A VGND VGND VPWR VPWR _4871_/Y sky130_fd_sc_hd__a31oi_2
XFILLER_32_253 VGND VGND VPWR VPWR sky130_fd_sc_hd__decap_3
X_6610_ _6610_/A VGND VGND VPWR VPWR _6610_/Y sky130_fd_sc_hd__inv_2
X_3822_ hold975/X _3909_/A2 _5010_/C VGND VGND VPWR VPWR _7389_/D sky130_fd_sc_hd__a21o_2
XTAP_TAPCELL_ROW_43_771 VGND VPWR sky130_fd_sc_hd__tapvpwrvgnd_1
XFILLER_60_595 VGND VGND VPWR VPWR sky130_fd_sc_hd__decap_3
X_6541_ _6604_/A VGND VGND VPWR VPWR _6541_/Y sky130_fd_sc_hd__inv_2
X_3753_ _3682_/A _3752_/X _5104_/A VGND VGND VPWR VPWR _3753_/X sky130_fd_sc_hd__a21o_2
X_6472_ _6634_/A VGND VGND VPWR VPWR _6472_/Y sky130_fd_sc_hd__inv_2
X_3684_ hold983/X _3709_/B1 _3683_/Y VGND VGND VPWR VPWR _7404_/D sky130_fd_sc_hd__a21bo_2
X_5423_ _5423_/A0 _5139_/X _5429_/S VGND VGND VPWR VPWR _7122_/D sky130_fd_sc_hd__mux2_2
X_5354_ _7154_/Q _5139_/X _5360_/S VGND VGND VPWR VPWR _7154_/D sky130_fd_sc_hd__mux2_2
X_4305_ _7064_/Q _4305_/B VGND VGND VPWR VPWR _4364_/B sky130_fd_sc_hd__nor2_2
XFILLER_99_242 VGND VGND VPWR VPWR sky130_fd_sc_hd__decap_3
XFILLER_101_203 VGND VGND VPWR VPWR sky130_fd_sc_hd__fill_1
XFILLER_101_214 VGND VGND VPWR VPWR sky130_fd_sc_hd__decap_3
XFILLER_114_575 VGND VGND VPWR VPWR sky130_fd_sc_hd__decap_3
XFILLER_59_117 VGND VGND VPWR VPWR sky130_fd_sc_hd__decap_3
XFILLER_114_15 VGND VGND VPWR VPWR sky130_fd_sc_hd__decap_3
XFILLER_4_80 VGND VGND VPWR VPWR sky130_fd_sc_hd__decap_3
XFILLER_4_91 VGND VGND VPWR VPWR sky130_fd_sc_hd__decap_3
XFILLER_68_640 VGND VGND VPWR VPWR sky130_fd_sc_hd__decap_3
X_7024_ _7338_/CLK _7024_/D _6304_/Y VGND VGND VPWR VPWR _7024_/Q sky130_fd_sc_hd__dfrtp_2
X_4236_ _7163_/Q _4339_/B1 _4234_/X _4235_/X VGND VGND VPWR VPWR _4236_/X sky130_fd_sc_hd__a211o_2
XFILLER_28_515 VGND VGND VPWR VPWR sky130_fd_sc_hd__fill_1
XFILLER_67_150 VGND VGND VPWR VPWR sky130_fd_sc_hd__decap_3
XFILLER_68_651 VGND VGND VPWR VPWR sky130_fd_sc_hd__decap_3
X_4167_ _7393_/Q _4196_/A2 _4865_/S _7297_/Q _4166_/X VGND VGND VPWR VPWR _4167_/X
+ sky130_fd_sc_hd__a221o_2
XFILLER_114_59 VGND VGND VPWR VPWR sky130_fd_sc_hd__decap_3
XFILLER_67_161 VGND VGND VPWR VPWR sky130_fd_sc_hd__decap_3
XFILLER_67_183 VGND VGND VPWR VPWR sky130_fd_sc_hd__decap_3
XFILLER_95_470 VGND VGND VPWR VPWR sky130_fd_sc_hd__decap_3
XFILLER_82_153 VGND VGND VPWR VPWR sky130_fd_sc_hd__decap_3
XFILLER_83_676 VGND VGND VPWR VPWR sky130_fd_sc_hd__decap_3
X_4098_ _7333_/Q _3949_/S _4419_/B1 _7365_/Q _4419_/C1 VGND VGND VPWR VPWR _4098_/X
+ sky130_fd_sc_hd__a221o_2
XFILLER_82_186 VGND VGND VPWR VPWR sky130_fd_sc_hd__fill_1
XFILLER_36_592 VGND VGND VPWR VPWR sky130_fd_sc_hd__decap_3
XFILLER_82_197 VGND VGND VPWR VPWR sky130_fd_sc_hd__decap_3
XFILLER_23_12 VGND VGND VPWR VPWR sky130_fd_sc_hd__decap_3
XFILLER_90_29 VGND VGND VPWR VPWR sky130_fd_sc_hd__decap_3
X_6808_ _6976_/CLK _6808_/D VGND VGND VPWR VPWR _6808_/Q sky130_fd_sc_hd__dfxtp_2
XFILLER_11_437 VGND VGND VPWR VPWR sky130_fd_sc_hd__fill_1
XFILLER_23_45 VGND VGND VPWR VPWR sky130_fd_sc_hd__decap_3
XFILLER_51_595 VGND VGND VPWR VPWR sky130_fd_sc_hd__decap_3
XFILLER_23_78 VGND VGND VPWR VPWR sky130_fd_sc_hd__decap_3
XFILLER_7_419 VGND VGND VPWR VPWR sky130_fd_sc_hd__fill_1
X_6739_ _6978_/CLK _6739_/D VGND VGND VPWR VPWR _6739_/Q sky130_fd_sc_hd__dfxtp_2
XFILLER_99_27 VGND VGND VPWR VPWR sky130_fd_sc_hd__decap_3
XFILLER_109_358 VGND VGND VPWR VPWR sky130_fd_sc_hd__fill_1
XTAP_TAPCELL_ROW_21_498 VGND VPWR sky130_fd_sc_hd__tapvpwrvgnd_1
XFILLER_105_520 VGND VGND VPWR VPWR sky130_fd_sc_hd__decap_3
XFILLER_105_531 VGND VGND VPWR VPWR sky130_fd_sc_hd__decap_3
XFILLER_2_124 VGND VGND VPWR VPWR sky130_fd_sc_hd__decap_3
XFILLER_3_647 VGND VGND VPWR VPWR sky130_fd_sc_hd__decap_3
XFILLER_105_564 VGND VGND VPWR VPWR sky130_fd_sc_hd__decap_3
XFILLER_78_415 VGND VGND VPWR VPWR sky130_fd_sc_hd__decap_3
XFILLER_78_448 VGND VGND VPWR VPWR sky130_fd_sc_hd__decap_3
XFILLER_48_75 VGND VGND VPWR VPWR sky130_fd_sc_hd__decap_3
XFILLER_58_150 VGND VGND VPWR VPWR sky130_fd_sc_hd__decap_3
XFILLER_59_662 VGND VGND VPWR VPWR sky130_fd_sc_hd__decap_3
XFILLER_59_673 VGND VGND VPWR VPWR sky130_fd_sc_hd__decap_3
XFILLER_46_312 VGND VGND VPWR VPWR sky130_fd_sc_hd__fill_2
XFILLER_46_323 VGND VGND VPWR VPWR sky130_fd_sc_hd__decap_3
XFILLER_58_183 VGND VGND VPWR VPWR sky130_fd_sc_hd__decap_3
XFILLER_74_610 VGND VGND VPWR VPWR sky130_fd_sc_hd__decap_3
XFILLER_0_38 VGND VGND VPWR VPWR sky130_fd_sc_hd__decap_3
XFILLER_74_654 VGND VGND VPWR VPWR sky130_fd_sc_hd__decap_3
XFILLER_61_326 VGND VGND VPWR VPWR sky130_fd_sc_hd__decap_3
XFILLER_64_41 VGND VGND VPWR VPWR sky130_fd_sc_hd__decap_3
XFILLER_73_186 VGND VGND VPWR VPWR sky130_fd_sc_hd__decap_3
XFILLER_74_687 VGND VGND VPWR VPWR sky130_fd_sc_hd__decap_3
XFILLER_61_337 VGND VGND VPWR VPWR sky130_fd_sc_hd__decap_3
XFILLER_64_74 VGND VGND VPWR VPWR sky130_fd_sc_hd__decap_3
XTAP_TAPCELL_ROW_64_1021 VGND VPWR sky130_fd_sc_hd__tapvpwrvgnd_1
XTAP_TAPCELL_ROW_29_598 VGND VPWR sky130_fd_sc_hd__tapvpwrvgnd_1
XFILLER_14_242 VGND VGND VPWR VPWR sky130_fd_sc_hd__fill_2
XFILLER_14_253 VGND VGND VPWR VPWR sky130_fd_sc_hd__decap_3
XFILLER_9_36 VGND VGND VPWR VPWR sky130_fd_sc_hd__decap_3
XFILLER_42_584 VGND VGND VPWR VPWR sky130_fd_sc_hd__decap_3
XFILLER_42_595 VGND VGND VPWR VPWR sky130_fd_sc_hd__fill_1
XFILLER_9_69 VGND VGND VPWR VPWR sky130_fd_sc_hd__decap_3
XFILLER_80_62 VGND VGND VPWR VPWR sky130_fd_sc_hd__decap_3
XTAP_TAPCELL_ROW_40_730 VGND VPWR sky130_fd_sc_hd__tapvpwrvgnd_1
Xhold909 _6701_/Q VGND VGND VPWR VPWR hold909/X sky130_fd_sc_hd__dlygate4sd3_1
XFILLER_108_380 VGND VGND VPWR VPWR sky130_fd_sc_hd__fill_2
XFILLER_6_474 VGND VGND VPWR VPWR sky130_fd_sc_hd__fill_2
XFILLER_89_60 VGND VGND VPWR VPWR sky130_fd_sc_hd__decap_3
XFILLER_89_93 VGND VGND VPWR VPWR sky130_fd_sc_hd__decap_3
XTAP_TAPCELL_ROW_75_1150 VGND VPWR sky130_fd_sc_hd__tapvpwrvgnd_1
XFILLER_111_501 VGND VGND VPWR VPWR sky130_fd_sc_hd__decap_3
XFILLER_69_415 VGND VGND VPWR VPWR sky130_fd_sc_hd__decap_3
XFILLER_111_523 VGND VGND VPWR VPWR sky130_fd_sc_hd__decap_3
XFILLER_96_234 VGND VGND VPWR VPWR sky130_fd_sc_hd__decap_3
X_5070_ _5073_/A _5050_/X _5053_/Y VGND VGND VPWR VPWR _5075_/A sky130_fd_sc_hd__o21a_2
XFILLER_29_3 VGND VGND VPWR VPWR sky130_fd_sc_hd__decap_3
XFILLER_96_256 VGND VGND VPWR VPWR sky130_fd_sc_hd__fill_1
XFILLER_96_278 VGND VGND VPWR VPWR sky130_fd_sc_hd__decap_3
XFILLER_49_183 VGND VGND VPWR VPWR sky130_fd_sc_hd__decap_3
XFILLER_65_632 VGND VGND VPWR VPWR sky130_fd_sc_hd__decap_3
XFILLER_77_470 VGND VGND VPWR VPWR sky130_fd_sc_hd__decap_3
XTAP_TAPCELL_ROW_48_830 VGND VPWR sky130_fd_sc_hd__tapvpwrvgnd_1
XFILLER_37_334 VGND VGND VPWR VPWR sky130_fd_sc_hd__fill_2
XFILLER_65_665 VGND VGND VPWR VPWR sky130_fd_sc_hd__decap_3
XFILLER_65_676 VGND VGND VPWR VPWR sky130_fd_sc_hd__decap_3
XFILLER_92_440 VGND VGND VPWR VPWR sky130_fd_sc_hd__decap_3
XFILLER_25_518 VGND VGND VPWR VPWR sky130_fd_sc_hd__decap_3
XFILLER_52_304 VGND VGND VPWR VPWR sky130_fd_sc_hd__decap_3
XFILLER_52_315 VGND VGND VPWR VPWR sky130_fd_sc_hd__decap_3
XFILLER_92_495 VGND VGND VPWR VPWR sky130_fd_sc_hd__decap_3
XFILLER_52_348 VGND VGND VPWR VPWR sky130_fd_sc_hd__decap_3
XFILLER_64_197 VGND VGND VPWR VPWR sky130_fd_sc_hd__fill_1
X_4923_ _4920_/A _4922_/X _4969_/B VGND VGND VPWR VPWR _4923_/Y sky130_fd_sc_hd__o21ai_2
X_4854_ _4764_/B _4096_/A _4633_/A _5101_/A VGND VGND VPWR VPWR _4854_/X sky130_fd_sc_hd__o22a_2
X_4785_ _4785_/A _4811_/B VGND VGND VPWR VPWR _4795_/B sky130_fd_sc_hd__nand2_2
X_3805_ _6948_/Q _3913_/B1 _3869_/B1 _6960_/Q VGND VGND VPWR VPWR _3805_/X sky130_fd_sc_hd__a22o_2
X_6524_ _6647_/A VGND VGND VPWR VPWR _6524_/Y sky130_fd_sc_hd__inv_2
XFILLER_109_15 VGND VGND VPWR VPWR sky130_fd_sc_hd__decap_3
XFILLER_9_290 VGND VGND VPWR VPWR sky130_fd_sc_hd__decap_3
XFILLER_106_339 VGND VGND VPWR VPWR sky130_fd_sc_hd__fill_2
XFILLER_109_48 VGND VGND VPWR VPWR sky130_fd_sc_hd__decap_3
X_6455_ _6584_/A VGND VGND VPWR VPWR _6455_/Y sky130_fd_sc_hd__inv_2
X_6386_ _6547_/A VGND VGND VPWR VPWR _6386_/Y sky130_fd_sc_hd__inv_2
X_3598_ _3598_/A _3611_/B VGND VGND VPWR VPWR _4614_/B sky130_fd_sc_hd__nor2_2
XFILLER_0_617 VGND VGND VPWR VPWR sky130_fd_sc_hd__decap_3
XFILLER_114_350 VGND VGND VPWR VPWR sky130_fd_sc_hd__decap_3
XFILLER_114_372 VGND VGND VPWR VPWR sky130_fd_sc_hd__decap_3
XFILLER_102_545 VGND VGND VPWR VPWR sky130_fd_sc_hd__decap_3
X_5268_ _5268_/A0 _5027_/X _5274_/S VGND VGND VPWR VPWR _7196_/D sky130_fd_sc_hd__mux2_2
XFILLER_85_29 VGND VGND VPWR VPWR sky130_fd_sc_hd__fill_2
XFILLER_87_267 VGND VGND VPWR VPWR sky130_fd_sc_hd__decap_3
X_7007_ _7341_/CLK _7007_/D _6287_/Y VGND VGND VPWR VPWR _7007_/Q sky130_fd_sc_hd__dfrtp_2
X_4219_ _7292_/Q _5080_/S _4352_/B1 _7164_/Q _4218_/X VGND VGND VPWR VPWR _4219_/X
+ sky130_fd_sc_hd__a221o_2
XTAP_TAPCELL_ROW_89_1319 VGND VPWR sky130_fd_sc_hd__tapvpwrvgnd_1
XFILLER_18_12 VGND VGND VPWR VPWR sky130_fd_sc_hd__decap_3
XFILLER_56_621 VGND VGND VPWR VPWR sky130_fd_sc_hd__decap_3
XFILLER_68_470 VGND VGND VPWR VPWR sky130_fd_sc_hd__fill_2
XFILLER_68_492 VGND VGND VPWR VPWR sky130_fd_sc_hd__decap_3
XFILLER_75_429 VGND VGND VPWR VPWR sky130_fd_sc_hd__decap_3
XFILLER_18_56 VGND VGND VPWR VPWR sky130_fd_sc_hd__decap_3
XFILLER_56_654 VGND VGND VPWR VPWR sky130_fd_sc_hd__decap_3
XFILLER_43_326 VGND VGND VPWR VPWR sky130_fd_sc_hd__decap_3
XFILLER_55_164 VGND VGND VPWR VPWR sky130_fd_sc_hd__decap_3
XFILLER_55_175 VGND VGND VPWR VPWR sky130_fd_sc_hd__decap_3
XFILLER_56_687 VGND VGND VPWR VPWR sky130_fd_sc_hd__decap_3
XFILLER_70_101 VGND VGND VPWR VPWR sky130_fd_sc_hd__decap_3
XFILLER_71_635 VGND VGND VPWR VPWR sky130_fd_sc_hd__decap_3
XFILLER_83_484 VGND VGND VPWR VPWR sky130_fd_sc_hd__decap_3
XFILLER_43_337 VGND VGND VPWR VPWR sky130_fd_sc_hd__fill_2
XFILLER_55_186 VGND VGND VPWR VPWR sky130_fd_sc_hd__decap_3
XFILLER_70_134 VGND VGND VPWR VPWR sky130_fd_sc_hd__decap_3
XFILLER_71_668 VGND VGND VPWR VPWR sky130_fd_sc_hd__fill_1
XFILLER_70_178 VGND VGND VPWR VPWR sky130_fd_sc_hd__decap_3
XFILLER_71_679 VGND VGND VPWR VPWR sky130_fd_sc_hd__decap_3
XTAP_TAPCELL_ROW_26_568 VGND VPWR sky130_fd_sc_hd__tapvpwrvgnd_1
XFILLER_11_223 VGND VGND VPWR VPWR sky130_fd_sc_hd__fill_1
XFILLER_24_584 VGND VGND VPWR VPWR sky130_fd_sc_hd__decap_3
XTAP_TAPCELL_ROW_54_899 VGND VPWR sky130_fd_sc_hd__tapvpwrvgnd_1
XFILLER_11_234 VGND VGND VPWR VPWR sky130_fd_sc_hd__decap_3
XFILLER_109_111 VGND VGND VPWR VPWR sky130_fd_sc_hd__fill_1
XFILLER_11_278 VGND VGND VPWR VPWR sky130_fd_sc_hd__fill_2
XFILLER_50_32 VGND VGND VPWR VPWR sky130_fd_sc_hd__decap_3
XFILLER_109_144 VGND VGND VPWR VPWR sky130_fd_sc_hd__decap_3
XFILLER_50_65 VGND VGND VPWR VPWR sky130_fd_sc_hd__decap_3
XFILLER_50_76 VGND VGND VPWR VPWR sky130_fd_sc_hd__decap_3
XFILLER_7_249 VGND VGND VPWR VPWR sky130_fd_sc_hd__fill_2
XFILLER_109_166 VGND VGND VPWR VPWR sky130_fd_sc_hd__fill_2
XFILLER_109_199 VGND VGND VPWR VPWR sky130_fd_sc_hd__decap_3
XFILLER_3_411 VGND VGND VPWR VPWR sky130_fd_sc_hd__decap_3
XFILLER_3_444 VGND VGND VPWR VPWR sky130_fd_sc_hd__decap_3
XFILLER_112_309 VGND VGND VPWR VPWR sky130_fd_sc_hd__fill_2
XFILLER_59_63 VGND VGND VPWR VPWR sky130_fd_sc_hd__fill_1
XFILLER_59_74 VGND VGND VPWR VPWR sky130_fd_sc_hd__fill_1
XFILLER_66_418 VGND VGND VPWR VPWR sky130_fd_sc_hd__fill_2
XFILLER_78_256 VGND VGND VPWR VPWR sky130_fd_sc_hd__fill_1
XFILLER_78_278 VGND VGND VPWR VPWR sky130_fd_sc_hd__decap_3
XFILLER_15_9 VGND VGND VPWR VPWR sky130_fd_sc_hd__decap_3
XFILLER_19_301 VGND VGND VPWR VPWR sky130_fd_sc_hd__decap_3
XFILLER_47_632 VGND VGND VPWR VPWR sky130_fd_sc_hd__decap_3
XFILLER_75_40 VGND VGND VPWR VPWR sky130_fd_sc_hd__decap_3
XFILLER_93_237 VGND VGND VPWR VPWR sky130_fd_sc_hd__decap_3
XTAP_TAPCELL_ROW_70_1091 VGND VPWR sky130_fd_sc_hd__tapvpwrvgnd_1
XFILLER_47_665 VGND VGND VPWR VPWR sky130_fd_sc_hd__decap_3
XFILLER_74_451 VGND VGND VPWR VPWR sky130_fd_sc_hd__decap_3
XTAP_TAPCELL_ROW_109_1555 VGND VPWR sky130_fd_sc_hd__tapvpwrvgnd_1
XFILLER_19_389 VGND VGND VPWR VPWR sky130_fd_sc_hd__decap_3
XFILLER_47_676 VGND VGND VPWR VPWR sky130_fd_sc_hd__decap_3
XFILLER_75_84 VGND VGND VPWR VPWR sky130_fd_sc_hd__decap_3
XFILLER_34_348 VGND VGND VPWR VPWR sky130_fd_sc_hd__fill_1
XFILLER_46_186 VGND VGND VPWR VPWR sky130_fd_sc_hd__decap_3
XFILLER_46_197 VGND VGND VPWR VPWR sky130_fd_sc_hd__decap_3
XFILLER_62_635 VGND VGND VPWR VPWR sky130_fd_sc_hd__decap_3
XFILLER_62_657 VGND VGND VPWR VPWR sky130_fd_sc_hd__decap_3
XFILLER_61_156 VGND VGND VPWR VPWR sky130_fd_sc_hd__decap_3
XFILLER_61_178 VGND VGND VPWR VPWR sky130_fd_sc_hd__decap_3
XFILLER_15_573 VGND VGND VPWR VPWR sky130_fd_sc_hd__decap_3
XFILLER_15_584 VGND VGND VPWR VPWR sky130_fd_sc_hd__decap_3
XFILLER_42_381 VGND VGND VPWR VPWR sky130_fd_sc_hd__decap_3
XFILLER_91_94 VGND VGND VPWR VPWR sky130_fd_sc_hd__decap_3
XFILLER_98_6 VGND VGND VPWR VPWR sky130_fd_sc_hd__decap_3
X_3521_ _3525_/A _3525_/B VGND VGND VPWR VPWR _3618_/C sky130_fd_sc_hd__nand2_2
XFILLER_116_615 VGND VGND VPWR VPWR sky130_fd_sc_hd__fill_1
XFILLER_116_626 VGND VGND VPWR VPWR sky130_fd_sc_hd__decap_3
XFILLER_116_648 VGND VGND VPWR VPWR sky130_fd_sc_hd__decap_3
Xhold706 _6902_/Q VGND VGND VPWR VPWR _6902_/D sky130_fd_sc_hd__dlygate4sd3_1
Xhold717 _6748_/Q VGND VGND VPWR VPWR _6748_/D sky130_fd_sc_hd__dlygate4sd3_1
Xhold728 _6723_/Q VGND VGND VPWR VPWR _6723_/D sky130_fd_sc_hd__dlygate4sd3_1
XFILLER_115_125 VGND VGND VPWR VPWR sky130_fd_sc_hd__decap_3
XFILLER_115_158 VGND VGND VPWR VPWR sky130_fd_sc_hd__decap_3
Xhold739 _6879_/Q VGND VGND VPWR VPWR _6879_/D sky130_fd_sc_hd__dlygate4sd3_1
XFILLER_115_169 VGND VGND VPWR VPWR sky130_fd_sc_hd__decap_3
X_3383_ _5118_/D _3383_/B VGND VGND VPWR VPWR _3383_/Y sky130_fd_sc_hd__nor2_2
XFILLER_69_234 VGND VGND VPWR VPWR sky130_fd_sc_hd__decap_3
X_5122_ _5122_/A0 _5121_/X _5136_/S VGND VGND VPWR VPWR _7254_/D sky130_fd_sc_hd__mux2_2
XFILLER_111_364 VGND VGND VPWR VPWR sky130_fd_sc_hd__decap_3
XFILLER_57_418 VGND VGND VPWR VPWR sky130_fd_sc_hd__decap_3
XFILLER_69_278 VGND VGND VPWR VPWR sky130_fd_sc_hd__fill_2
XFILLER_38_621 VGND VGND VPWR VPWR sky130_fd_sc_hd__decap_3
XFILLER_84_215 VGND VGND VPWR VPWR sky130_fd_sc_hd__decap_3
X_5053_ _5073_/A _5050_/X _3522_/Y VGND VGND VPWR VPWR _5053_/Y sky130_fd_sc_hd__a21oi_2
XFILLER_37_120 VGND VGND VPWR VPWR sky130_fd_sc_hd__decap_3
XFILLER_38_665 VGND VGND VPWR VPWR sky130_fd_sc_hd__decap_3
XFILLER_1_81 VGND VGND VPWR VPWR sky130_fd_sc_hd__decap_3
XFILLER_37_164 VGND VGND VPWR VPWR sky130_fd_sc_hd__decap_3
XFILLER_37_175 VGND VGND VPWR VPWR sky130_fd_sc_hd__decap_3
XFILLER_53_613 VGND VGND VPWR VPWR sky130_fd_sc_hd__decap_3
XFILLER_65_484 VGND VGND VPWR VPWR sky130_fd_sc_hd__decap_3
XFILLER_80_410 VGND VGND VPWR VPWR sky130_fd_sc_hd__decap_3
XFILLER_111_16 VGND VGND VPWR VPWR sky130_fd_sc_hd__decap_3
XFILLER_53_635 VGND VGND VPWR VPWR sky130_fd_sc_hd__decap_3
XFILLER_80_421 VGND VGND VPWR VPWR sky130_fd_sc_hd__fill_2
XFILLER_111_49 VGND VGND VPWR VPWR sky130_fd_sc_hd__decap_3
XFILLER_40_307 VGND VGND VPWR VPWR sky130_fd_sc_hd__fill_1
XFILLER_52_156 VGND VGND VPWR VPWR sky130_fd_sc_hd__decap_3
XFILLER_53_679 VGND VGND VPWR VPWR sky130_fd_sc_hd__decap_3
XFILLER_40_318 VGND VGND VPWR VPWR sky130_fd_sc_hd__decap_3
XFILLER_40_329 VGND VGND VPWR VPWR sky130_fd_sc_hd__decap_3
XFILLER_52_189 VGND VGND VPWR VPWR sky130_fd_sc_hd__decap_3
X_4906_ _4814_/A _4886_/C _4904_/X _4905_/X VGND VGND VPWR VPWR _4906_/X sky130_fd_sc_hd__o31a_2
XTAP_TAPCELL_ROW_23_527 VGND VPWR sky130_fd_sc_hd__tapvpwrvgnd_1
XFILLER_21_532 VGND VGND VPWR VPWR sky130_fd_sc_hd__decap_3
X_4837_ _4837_/A0 _4836_/X _4879_/S VGND VGND VPWR VPWR _7271_/D sky130_fd_sc_hd__mux2_2
XTAP_TAPCELL_ROW_51_869 VGND VPWR sky130_fd_sc_hd__tapvpwrvgnd_1
XTAP_TAPCELL_ROW_51_858 VGND VPWR sky130_fd_sc_hd__tapvpwrvgnd_1
XFILLER_107_604 VGND VGND VPWR VPWR sky130_fd_sc_hd__decap_3
X_4768_ _4762_/Y _4763_/X _4767_/X VGND VGND VPWR VPWR _4768_/Y sky130_fd_sc_hd__o21ai_2
XFILLER_106_103 VGND VGND VPWR VPWR sky130_fd_sc_hd__decap_3
X_6507_ _6532_/A VGND VGND VPWR VPWR _6507_/Y sky130_fd_sc_hd__inv_2
X_4699_ _6986_/Q _6987_/Q _5098_/A VGND VGND VPWR VPWR _5066_/A sky130_fd_sc_hd__and3_2
XFILLER_107_659 VGND VGND VPWR VPWR sky130_fd_sc_hd__decap_3
XFILLER_20_35 VGND VGND VPWR VPWR sky130_fd_sc_hd__decap_3
XFILLER_20_68 VGND VGND VPWR VPWR sky130_fd_sc_hd__fill_1
X_6438_ _6532_/A VGND VGND VPWR VPWR _6438_/Y sky130_fd_sc_hd__inv_2
XFILLER_106_169 VGND VGND VPWR VPWR sky130_fd_sc_hd__decap_3
XFILLER_20_79 VGND VGND VPWR VPWR sky130_fd_sc_hd__decap_3
XFILLER_96_17 VGND VGND VPWR VPWR sky130_fd_sc_hd__decap_3
XTAP_TAPCELL_ROW_95_1389 VGND VPWR sky130_fd_sc_hd__tapvpwrvgnd_1
XFILLER_0_436 VGND VGND VPWR VPWR sky130_fd_sc_hd__fill_2
XFILLER_102_320 VGND VGND VPWR VPWR sky130_fd_sc_hd__decap_3
XFILLER_114_180 VGND VGND VPWR VPWR sky130_fd_sc_hd__decap_3
X_6369_ _6532_/A VGND VGND VPWR VPWR _6369_/Y sky130_fd_sc_hd__inv_2
XFILLER_0_458 VGND VGND VPWR VPWR sky130_fd_sc_hd__decap_3
XFILLER_29_33 VGND VGND VPWR VPWR sky130_fd_sc_hd__decap_3
XFILLER_102_386 VGND VGND VPWR VPWR sky130_fd_sc_hd__decap_3
XFILLER_29_66 VGND VGND VPWR VPWR sky130_fd_sc_hd__decap_3
XFILLER_88_598 VGND VGND VPWR VPWR sky130_fd_sc_hd__decap_3
XFILLER_75_259 VGND VGND VPWR VPWR sky130_fd_sc_hd__decap_3
XTAP_TAPCELL_ROW_59_958 VGND VPWR sky130_fd_sc_hd__tapvpwrvgnd_1
XFILLER_28_153 VGND VGND VPWR VPWR sky130_fd_sc_hd__decap_3
XFILLER_44_624 VGND VGND VPWR VPWR sky130_fd_sc_hd__decap_3
XFILLER_45_21 VGND VGND VPWR VPWR sky130_fd_sc_hd__decap_3
XTAP_TAPCELL_ROW_3_285 VGND VPWR sky130_fd_sc_hd__tapvpwrvgnd_1
XFILLER_28_186 VGND VGND VPWR VPWR sky130_fd_sc_hd__decap_3
XFILLER_28_197 VGND VGND VPWR VPWR sky130_fd_sc_hd__decap_3
XFILLER_44_657 VGND VGND VPWR VPWR sky130_fd_sc_hd__decap_3
XFILLER_45_54 VGND VGND VPWR VPWR sky130_fd_sc_hd__fill_2
XFILLER_45_65 VGND VGND VPWR VPWR sky130_fd_sc_hd__decap_3
XFILLER_83_281 VGND VGND VPWR VPWR sky130_fd_sc_hd__fill_1
XFILLER_43_156 VGND VGND VPWR VPWR sky130_fd_sc_hd__fill_1
XFILLER_45_87 VGND VGND VPWR VPWR sky130_fd_sc_hd__decap_3
XFILLER_52_690 VGND VGND VPWR VPWR sky130_fd_sc_hd__fill_2
XFILLER_71_498 VGND VGND VPWR VPWR sky130_fd_sc_hd__decap_3
XFILLER_24_392 VGND VGND VPWR VPWR sky130_fd_sc_hd__fill_1
XFILLER_61_31 VGND VGND VPWR VPWR sky130_fd_sc_hd__decap_3
XTAP_TAPCELL_ROW_104_1496 VGND VPWR sky130_fd_sc_hd__tapvpwrvgnd_1
XFILLER_61_75 VGND VGND VPWR VPWR sky130_fd_sc_hd__decap_3
XFILLER_8_536 VGND VGND VPWR VPWR sky130_fd_sc_hd__decap_3
XFILLER_6_15 VGND VGND VPWR VPWR sky130_fd_sc_hd__decap_3
XFILLER_6_59 VGND VGND VPWR VPWR sky130_fd_sc_hd__decap_3
XFILLER_112_106 VGND VGND VPWR VPWR sky130_fd_sc_hd__decap_3
XFILLER_113_629 VGND VGND VPWR VPWR sky130_fd_sc_hd__decap_3
XFILLER_3_252 VGND VGND VPWR VPWR sky130_fd_sc_hd__decap_3
XFILLER_106_681 VGND VGND VPWR VPWR sky130_fd_sc_hd__decap_3
XFILLER_112_139 VGND VGND VPWR VPWR sky130_fd_sc_hd__fill_1
XTAP_TAPCELL_ROW_72_1120 VGND VPWR sky130_fd_sc_hd__tapvpwrvgnd_1
XFILLER_66_215 VGND VGND VPWR VPWR sky130_fd_sc_hd__decap_3
XFILLER_66_226 VGND VGND VPWR VPWR sky130_fd_sc_hd__decap_3
XFILLER_86_61 VGND VGND VPWR VPWR sky130_fd_sc_hd__decap_3
XFILLER_86_94 VGND VGND VPWR VPWR sky130_fd_sc_hd__decap_3
XFILLER_94_557 VGND VGND VPWR VPWR sky130_fd_sc_hd__decap_3
XFILLER_19_153 VGND VGND VPWR VPWR sky130_fd_sc_hd__decap_3
XFILLER_19_175 VGND VGND VPWR VPWR sky130_fd_sc_hd__decap_3
XFILLER_34_123 VGND VGND VPWR VPWR sky130_fd_sc_hd__decap_3
XFILLER_62_421 VGND VGND VPWR VPWR sky130_fd_sc_hd__decap_3
XFILLER_34_156 VGND VGND VPWR VPWR sky130_fd_sc_hd__decap_3
XFILLER_34_189 VGND VGND VPWR VPWR sky130_fd_sc_hd__decap_3
XFILLER_50_627 VGND VGND VPWR VPWR sky130_fd_sc_hd__decap_3
XFILLER_30_373 VGND VGND VPWR VPWR sky130_fd_sc_hd__decap_3
X_5671_ _5671_/A _5671_/B VGND VGND VPWR VPWR _6983_/D sky130_fd_sc_hd__and2_2
X_4622_ _5072_/B _4621_/X _5071_/B VGND VGND VPWR VPWR _4622_/X sky130_fd_sc_hd__a21bo_2
X_7341_ _7341_/CLK _7341_/D _6621_/Y VGND VGND VPWR VPWR _7341_/Q sky130_fd_sc_hd__dfrtp_2
X_7272_ _7363_/CLK _7272_/D _6552_/Y VGND VGND VPWR VPWR _7272_/Q sky130_fd_sc_hd__dfrtp_2
X_4484_ _4484_/A0 _7305_/Q _4488_/S VGND VGND VPWR VPWR _7337_/D sky130_fd_sc_hd__mux2_2
X_3504_ _3501_/X _3502_/X _3630_/A VGND VGND VPWR VPWR _3505_/B sky130_fd_sc_hd__a21oi_2
XFILLER_116_467 VGND VGND VPWR VPWR sky130_fd_sc_hd__fill_1
XFILLER_116_489 VGND VGND VPWR VPWR sky130_fd_sc_hd__decap_3
XFILLER_89_318 VGND VGND VPWR VPWR sky130_fd_sc_hd__decap_3
XFILLER_106_27 VGND VGND VPWR VPWR sky130_fd_sc_hd__fill_1
XFILLER_106_38 VGND VGND VPWR VPWR sky130_fd_sc_hd__decap_3
XFILLER_112_640 VGND VGND VPWR VPWR sky130_fd_sc_hd__decap_3
XFILLER_112_651 VGND VGND VPWR VPWR sky130_fd_sc_hd__decap_3
XFILLER_97_351 VGND VGND VPWR VPWR sky130_fd_sc_hd__decap_3
X_3366_ _3376_/A _3376_/B _3399_/B _5118_/A VGND VGND VPWR VPWR _3366_/X sky130_fd_sc_hd__o211a_2
XFILLER_111_172 VGND VGND VPWR VPWR sky130_fd_sc_hd__decap_3
XFILLER_112_684 VGND VGND VPWR VPWR sky130_fd_sc_hd__decap_3
XFILLER_57_204 VGND VGND VPWR VPWR sky130_fd_sc_hd__decap_3
XFILLER_97_373 VGND VGND VPWR VPWR sky130_fd_sc_hd__decap_3
Xhold1203 _7328_/Q VGND VGND VPWR VPWR _4503_/A0 sky130_fd_sc_hd__dlygate4sd3_1
Xhold1214 _7009_/Q VGND VGND VPWR VPWR _7009_/D sky130_fd_sc_hd__dlygate4sd3_1
X_5105_ _4467_/B _3874_/X _5104_/Y _5666_/A VGND VGND VPWR VPWR _5105_/X sky130_fd_sc_hd__a31o_2
XFILLER_111_194 VGND VGND VPWR VPWR sky130_fd_sc_hd__decap_3
XFILLER_57_248 VGND VGND VPWR VPWR sky130_fd_sc_hd__decap_3
X_5036_ _5036_/A _4674_/X VGND VGND VPWR VPWR _5038_/A sky130_fd_sc_hd__or2b_2
XFILLER_26_613 VGND VGND VPWR VPWR sky130_fd_sc_hd__decap_3
XFILLER_38_473 VGND VGND VPWR VPWR sky130_fd_sc_hd__decap_3
XTAP_TAPCELL_ROW_56_928 VGND VPWR sky130_fd_sc_hd__tapvpwrvgnd_1
XFILLER_25_123 VGND VGND VPWR VPWR sky130_fd_sc_hd__decap_3
XFILLER_38_495 VGND VGND VPWR VPWR sky130_fd_sc_hd__fill_1
XFILLER_53_432 VGND VGND VPWR VPWR sky130_fd_sc_hd__decap_3
XFILLER_65_281 VGND VGND VPWR VPWR sky130_fd_sc_hd__decap_3
XFILLER_72_229 VGND VGND VPWR VPWR sky130_fd_sc_hd__decap_3
XTAP_TAPCELL_ROW_0_244 VGND VPWR sky130_fd_sc_hd__tapvpwrvgnd_1
XFILLER_25_134 VGND VGND VPWR VPWR sky130_fd_sc_hd__decap_3
X_6987_ _7401_/CLK _6987_/D _6267_/Y VGND VGND VPWR VPWR _6987_/Q sky130_fd_sc_hd__dfrtp_2
XTAP_TAPCELL_ROW_0_255 VGND VPWR sky130_fd_sc_hd__tapvpwrvgnd_1
XFILLER_15_24 VGND VGND VPWR VPWR sky130_fd_sc_hd__decap_3
XFILLER_15_57 VGND VGND VPWR VPWR sky130_fd_sc_hd__decap_3
XFILLER_40_126 VGND VGND VPWR VPWR sky130_fd_sc_hd__decap_3
XTAP_TAPCELL_ROW_36_685 VGND VPWR sky130_fd_sc_hd__tapvpwrvgnd_1
XFILLER_21_362 VGND VGND VPWR VPWR sky130_fd_sc_hd__fill_1
XFILLER_21_373 VGND VGND VPWR VPWR sky130_fd_sc_hd__decap_3
XFILLER_21_384 VGND VGND VPWR VPWR sky130_fd_sc_hd__decap_3
XFILLER_31_23 VGND VGND VPWR VPWR sky130_fd_sc_hd__decap_3
XTAP_TAPCELL_ROW_97_1418 VGND VPWR sky130_fd_sc_hd__tapvpwrvgnd_1
XFILLER_31_45 VGND VGND VPWR VPWR sky130_fd_sc_hd__decap_3
XFILLER_107_445 VGND VGND VPWR VPWR sky130_fd_sc_hd__decap_3
XFILLER_31_89 VGND VGND VPWR VPWR sky130_fd_sc_hd__decap_3
XFILLER_107_489 VGND VGND VPWR VPWR sky130_fd_sc_hd__decap_3
XTAP_TAPCELL_ROW_8_344 VGND VPWR sky130_fd_sc_hd__tapvpwrvgnd_1
XFILLER_0_222 VGND VGND VPWR VPWR sky130_fd_sc_hd__fill_2
XFILLER_103_651 VGND VGND VPWR VPWR sky130_fd_sc_hd__decap_3
XFILLER_88_340 VGND VGND VPWR VPWR sky130_fd_sc_hd__fill_1
XFILLER_0_277 VGND VGND VPWR VPWR sky130_fd_sc_hd__decap_3
XFILLER_103_673 VGND VGND VPWR VPWR sky130_fd_sc_hd__decap_3
XFILLER_88_362 VGND VGND VPWR VPWR sky130_fd_sc_hd__fill_2
XFILLER_88_384 VGND VGND VPWR VPWR sky130_fd_sc_hd__decap_3
XFILLER_102_194 VGND VGND VPWR VPWR sky130_fd_sc_hd__fill_2
XFILLER_76_557 VGND VGND VPWR VPWR sky130_fd_sc_hd__decap_3
XFILLER_29_473 VGND VGND VPWR VPWR sky130_fd_sc_hd__fill_1
XFILLER_16_112 VGND VGND VPWR VPWR sky130_fd_sc_hd__decap_3
XFILLER_17_646 VGND VGND VPWR VPWR sky130_fd_sc_hd__decap_3
XFILLER_29_495 VGND VGND VPWR VPWR sky130_fd_sc_hd__fill_1
XFILLER_44_421 VGND VGND VPWR VPWR sky130_fd_sc_hd__decap_3
XFILLER_56_292 VGND VGND VPWR VPWR sky130_fd_sc_hd__decap_3
XFILLER_63_229 VGND VGND VPWR VPWR sky130_fd_sc_hd__decap_3
XFILLER_91_549 VGND VGND VPWR VPWR sky130_fd_sc_hd__fill_2
XTAP_TAPCELL_ROW_106_1525 VGND VPWR sky130_fd_sc_hd__tapvpwrvgnd_1
XFILLER_16_156 VGND VGND VPWR VPWR sky130_fd_sc_hd__decap_3
XFILLER_17_657 VGND VGND VPWR VPWR sky130_fd_sc_hd__decap_3
XFILLER_17_668 VGND VGND VPWR VPWR sky130_fd_sc_hd__decap_3
XPHY_EDGE_ROW_113_Right_113 VGND VGND VPWR VPWR sky130_fd_sc_hd__decap_3
XFILLER_32_627 VGND VGND VPWR VPWR sky130_fd_sc_hd__decap_3
XFILLER_71_284 VGND VGND VPWR VPWR sky130_fd_sc_hd__decap_3
XFILLER_72_63 VGND VGND VPWR VPWR sky130_fd_sc_hd__decap_3
XFILLER_72_85 VGND VGND VPWR VPWR sky130_fd_sc_hd__fill_1
XFILLER_12_351 VGND VGND VPWR VPWR sky130_fd_sc_hd__decap_3
XFILLER_40_671 VGND VGND VPWR VPWR sky130_fd_sc_hd__decap_3
XFILLER_72_96 VGND VGND VPWR VPWR sky130_fd_sc_hd__decap_3
XFILLER_82_9 VGND VGND VPWR VPWR sky130_fd_sc_hd__decap_3
XFILLER_8_388 VGND VGND VPWR VPWR sky130_fd_sc_hd__fill_2
XFILLER_8_399 VGND VGND VPWR VPWR sky130_fd_sc_hd__decap_3
XFILLER_113_404 VGND VGND VPWR VPWR sky130_fd_sc_hd__decap_3
XFILLER_113_437 VGND VGND VPWR VPWR sky130_fd_sc_hd__decap_3
XFILLER_98_126 VGND VGND VPWR VPWR sky130_fd_sc_hd__decap_3
XFILLER_79_340 VGND VGND VPWR VPWR sky130_fd_sc_hd__decap_3
XFILLER_98_159 VGND VGND VPWR VPWR sky130_fd_sc_hd__decap_3
XFILLER_39_215 VGND VGND VPWR VPWR sky130_fd_sc_hd__decap_3
XFILLER_79_362 VGND VGND VPWR VPWR sky130_fd_sc_hd__decap_3
XFILLER_11_3 VGND VGND VPWR VPWR sky130_fd_sc_hd__decap_3
XFILLER_39_237 VGND VGND VPWR VPWR sky130_fd_sc_hd__decap_3
XFILLER_94_376 VGND VGND VPWR VPWR sky130_fd_sc_hd__decap_3
XFILLER_47_292 VGND VGND VPWR VPWR sky130_fd_sc_hd__decap_3
X_6910_ _6976_/CLK _6910_/D VGND VGND VPWR VPWR _6910_/Q sky130_fd_sc_hd__dfxtp_2
XFILLER_62_240 VGND VGND VPWR VPWR sky130_fd_sc_hd__decap_3
X_6841_ _6964_/CLK _6841_/D VGND VGND VPWR VPWR _6841_/Q sky130_fd_sc_hd__dfxtp_2
XFILLER_22_115 VGND VGND VPWR VPWR sky130_fd_sc_hd__decap_3
XFILLER_62_273 VGND VGND VPWR VPWR sky130_fd_sc_hd__decap_3
XTAP_TAPCELL_ROW_81_1219 VGND VPWR sky130_fd_sc_hd__tapvpwrvgnd_1
X_6772_ _6965_/CLK _6772_/D VGND VGND VPWR VPWR _6772_/Q sky130_fd_sc_hd__dfxtp_2
XTAP_TAPCELL_ROW_33_644 VGND VPWR sky130_fd_sc_hd__tapvpwrvgnd_1
XFILLER_31_671 VGND VGND VPWR VPWR sky130_fd_sc_hd__fill_1
X_5723_ _7367_/Q hold938/X _5737_/S VGND VGND VPWR VPWR _6711_/D sky130_fd_sc_hd__mux2_2
XTAP_TAPCELL_ROW_61_986 VGND VPWR sky130_fd_sc_hd__tapvpwrvgnd_1
XFILLER_30_170 VGND VGND VPWR VPWR sky130_fd_sc_hd__decap_3
X_5654_ _5665_/A VGND VGND VPWR VPWR _5654_/Y sky130_fd_sc_hd__inv_2
XFILLER_116_231 VGND VGND VPWR VPWR sky130_fd_sc_hd__decap_3
X_7324_ _7358_/CLK _7324_/D _6604_/Y VGND VGND VPWR VPWR _7324_/Q sky130_fd_sc_hd__dfrtp_2
X_5585_ hold955/X _5587_/B _5106_/X VGND VGND VPWR VPWR _7036_/D sky130_fd_sc_hd__a21o_2
XFILLER_116_264 VGND VGND VPWR VPWR sky130_fd_sc_hd__decap_3
X_4536_ hold939/X _3398_/Y _3488_/X VGND VGND VPWR VPWR _7311_/D sky130_fd_sc_hd__a21o_2
XFILLER_104_437 VGND VGND VPWR VPWR sky130_fd_sc_hd__decap_3
XFILLER_89_137 VGND VGND VPWR VPWR sky130_fd_sc_hd__decap_3
X_7255_ clkload9/A _7255_/D _6535_/Y VGND VGND VPWR VPWR _7255_/Q sky130_fd_sc_hd__dfrtp_2
X_4467_ _4467_/A _4467_/B VGND VGND VPWR VPWR _4467_/Y sky130_fd_sc_hd__nor2_2
XTAP_TAPCELL_ROW_92_1359 VGND VPWR sky130_fd_sc_hd__tapvpwrvgnd_1
XFILLER_89_159 VGND VGND VPWR VPWR sky130_fd_sc_hd__decap_3
X_7186_ clkload4/A _7186_/D _6466_/Y VGND VGND VPWR VPWR _7186_/Q sky130_fd_sc_hd__dfrtp_2
X_4398_ _7338_/Q _3945_/S _4488_/S _7306_/Q VGND VGND VPWR VPWR _4398_/X sky130_fd_sc_hd__a22o_2
X_3418_ _7283_/Q _5136_/S _3417_/X _7091_/Q VGND VGND VPWR VPWR _3418_/X sky130_fd_sc_hd__a22o_2
XFILLER_98_660 VGND VGND VPWR VPWR sky130_fd_sc_hd__decap_3
XFILLER_112_470 VGND VGND VPWR VPWR sky130_fd_sc_hd__decap_3
XFILLER_58_502 VGND VGND VPWR VPWR sky130_fd_sc_hd__decap_3
Xhold1000 _7266_/Q VGND VGND VPWR VPWR _4933_/A0 sky130_fd_sc_hd__dlygate4sd3_1
X_3349_ _5129_/A _5294_/A VGND VGND VPWR VPWR _3350_/B sky130_fd_sc_hd__nand2_2
XTAP_TAPCELL_ROW_5_314 VGND VPWR sky130_fd_sc_hd__tapvpwrvgnd_1
XFILLER_100_632 VGND VGND VPWR VPWR sky130_fd_sc_hd__decap_3
XFILLER_100_654 VGND VGND VPWR VPWR sky130_fd_sc_hd__decap_3
XFILLER_85_321 VGND VGND VPWR VPWR sky130_fd_sc_hd__decap_3
Xhold1011 _7207_/Q VGND VGND VPWR VPWR _5245_/A0 sky130_fd_sc_hd__dlygate4sd3_1
Xhold1022 _7038_/Q VGND VGND VPWR VPWR _5581_/A0 sky130_fd_sc_hd__dlygate4sd3_1
Xhold1033 _7274_/Q VGND VGND VPWR VPWR _4793_/A0 sky130_fd_sc_hd__dlygate4sd3_1
XFILLER_100_687 VGND VGND VPWR VPWR sky130_fd_sc_hd__decap_3
XFILLER_93_18 VGND VGND VPWR VPWR sky130_fd_sc_hd__decap_3
Xhold1044 _7212_/Q VGND VGND VPWR VPWR _5236_/A0 sky130_fd_sc_hd__dlygate4sd3_1
Xhold1055 _7235_/Q VGND VGND VPWR VPWR _5186_/A sky130_fd_sc_hd__dlygate4sd3_1
Xhold1066 _7250_/Q VGND VGND VPWR VPWR _5140_/A0 sky130_fd_sc_hd__dlygate4sd3_1
XFILLER_26_12 VGND VGND VPWR VPWR sky130_fd_sc_hd__decap_3
XFILLER_26_421 VGND VGND VPWR VPWR sky130_fd_sc_hd__decap_3
Xhold1077 _7293_/Q VGND VGND VPWR VPWR _4575_/A sky130_fd_sc_hd__dlygate4sd3_1
Xhold1088 _7333_/Q VGND VGND VPWR VPWR _4493_/A0 sky130_fd_sc_hd__dlygate4sd3_1
Xhold1099 _7309_/Q VGND VGND VPWR VPWR _4542_/A sky130_fd_sc_hd__dlygate4sd3_1
X_5019_ _4243_/Y _5032_/B _4989_/X _5018_/Y VGND VGND VPWR VPWR _5020_/B sky130_fd_sc_hd__a22o_2
XFILLER_53_240 VGND VGND VPWR VPWR sky130_fd_sc_hd__decap_3
XFILLER_14_627 VGND VGND VPWR VPWR sky130_fd_sc_hd__decap_3
XFILLER_26_67 VGND VGND VPWR VPWR sky130_fd_sc_hd__decap_3
XFILLER_53_273 VGND VGND VPWR VPWR sky130_fd_sc_hd__decap_3
XFILLER_53_284 VGND VGND VPWR VPWR sky130_fd_sc_hd__decap_3
XFILLER_13_137 VGND VGND VPWR VPWR sky130_fd_sc_hd__fill_2
XFILLER_41_435 VGND VGND VPWR VPWR sky130_fd_sc_hd__decap_3
XFILLER_13_159 VGND VGND VPWR VPWR sky130_fd_sc_hd__decap_3
XTAP_TAPCELL_ROW_101_1466 VGND VPWR sky130_fd_sc_hd__tapvpwrvgnd_1
XFILLER_42_55 VGND VGND VPWR VPWR sky130_fd_sc_hd__fill_1
XFILLER_42_77 VGND VGND VPWR VPWR sky130_fd_sc_hd__decap_3
XFILLER_5_314 VGND VGND VPWR VPWR sky130_fd_sc_hd__decap_3
XFILLER_107_231 VGND VGND VPWR VPWR sky130_fd_sc_hd__decap_3
XFILLER_3_27 VGND VGND VPWR VPWR sky130_fd_sc_hd__decap_3
XFILLER_89_660 VGND VGND VPWR VPWR sky130_fd_sc_hd__decap_3
XFILLER_107_81 VGND VGND VPWR VPWR sky130_fd_sc_hd__decap_3
XFILLER_67_30 VGND VGND VPWR VPWR sky130_fd_sc_hd__decap_3
XFILLER_89_682 VGND VGND VPWR VPWR sky130_fd_sc_hd__decap_3
XTAP_TAPCELL_ROW_112_1595 VGND VPWR sky130_fd_sc_hd__tapvpwrvgnd_1
XFILLER_103_481 VGND VGND VPWR VPWR sky130_fd_sc_hd__fill_1
XFILLER_76_321 VGND VGND VPWR VPWR sky130_fd_sc_hd__decap_3
XFILLER_88_192 VGND VGND VPWR VPWR sky130_fd_sc_hd__decap_3
XFILLER_76_376 VGND VGND VPWR VPWR sky130_fd_sc_hd__decap_3
XFILLER_17_410 VGND VGND VPWR VPWR sky130_fd_sc_hd__decap_3
XFILLER_29_270 VGND VGND VPWR VPWR sky130_fd_sc_hd__decap_3
XFILLER_29_281 VGND VGND VPWR VPWR sky130_fd_sc_hd__decap_3
XFILLER_91_324 VGND VGND VPWR VPWR sky130_fd_sc_hd__decap_3
XFILLER_83_51 VGND VGND VPWR VPWR sky130_fd_sc_hd__decap_3
XTAP_TAPCELL_ROW_67_1052 VGND VPWR sky130_fd_sc_hd__tapvpwrvgnd_1
XFILLER_32_413 VGND VGND VPWR VPWR sky130_fd_sc_hd__fill_1
XFILLER_32_424 VGND VGND VPWR VPWR sky130_fd_sc_hd__decap_3
XFILLER_83_95 VGND VGND VPWR VPWR sky130_fd_sc_hd__decap_3
XFILLER_32_435 VGND VGND VPWR VPWR sky130_fd_sc_hd__decap_3
XFILLER_44_284 VGND VGND VPWR VPWR sky130_fd_sc_hd__decap_3
XTAP_TAPCELL_ROW_30_614 VGND VPWR sky130_fd_sc_hd__tapvpwrvgnd_1
XFILLER_12_192 VGND VGND VPWR VPWR sky130_fd_sc_hd__decap_3
XFILLER_8_141 VGND VGND VPWR VPWR sky130_fd_sc_hd__decap_3
XFILLER_9_664 VGND VGND VPWR VPWR sky130_fd_sc_hd__decap_3
XFILLER_59_3 VGND VGND VPWR VPWR sky130_fd_sc_hd__decap_3
XTAP_TAPCELL_ROW_10_371 VGND VPWR sky130_fd_sc_hd__tapvpwrvgnd_1
XFILLER_113_223 VGND VGND VPWR VPWR sky130_fd_sc_hd__fill_1
X_4321_ _7098_/Q _4321_/A2 _4351_/B1 _7130_/Q VGND VGND VPWR VPWR _4321_/X sky130_fd_sc_hd__a22o_2
XTAP_TAPCELL_ROW_78_1192 VGND VPWR sky130_fd_sc_hd__tapvpwrvgnd_1
XFILLER_99_413 VGND VGND VPWR VPWR sky130_fd_sc_hd__decap_3
XFILLER_113_234 VGND VGND VPWR VPWR sky130_fd_sc_hd__decap_3
X_7040_ _7386_/CLK _7040_/D _6320_/Y VGND VGND VPWR VPWR _7040_/Q sky130_fd_sc_hd__dfrtp_2
X_4252_ _7197_/Q _3968_/S _4272_/B _7357_/Q VGND VGND VPWR VPWR _4252_/X sky130_fd_sc_hd__a22o_2
XFILLER_99_468 VGND VGND VPWR VPWR sky130_fd_sc_hd__decap_3
XFILLER_101_429 VGND VGND VPWR VPWR sky130_fd_sc_hd__decap_3
XFILLER_67_321 VGND VGND VPWR VPWR sky130_fd_sc_hd__fill_1
X_4183_ _7360_/Q _4272_/B _4267_/B1 _7168_/Q _4182_/X VGND VGND VPWR VPWR _4183_/X
+ sky130_fd_sc_hd__a221o_2
XFILLER_67_354 VGND VGND VPWR VPWR sky130_fd_sc_hd__decap_3
XFILLER_82_302 VGND VGND VPWR VPWR sky130_fd_sc_hd__decap_3
XFILLER_95_685 VGND VGND VPWR VPWR sky130_fd_sc_hd__decap_3
XTAP_TAPCELL_ROW_38_703 VGND VPWR sky130_fd_sc_hd__tapvpwrvgnd_1
XFILLER_103_39 VGND VGND VPWR VPWR sky130_fd_sc_hd__decap_3
XFILLER_27_218 VGND VGND VPWR VPWR sky130_fd_sc_hd__fill_2
XFILLER_55_549 VGND VGND VPWR VPWR sky130_fd_sc_hd__decap_3
XFILLER_82_324 VGND VGND VPWR VPWR sky130_fd_sc_hd__decap_3
XFILLER_94_173 VGND VGND VPWR VPWR sky130_fd_sc_hd__decap_3
XFILLER_94_195 VGND VGND VPWR VPWR sky130_fd_sc_hd__fill_1
XFILLER_70_519 VGND VGND VPWR VPWR sky130_fd_sc_hd__decap_3
XFILLER_82_357 VGND VGND VPWR VPWR sky130_fd_sc_hd__decap_3
XFILLER_82_368 VGND VGND VPWR VPWR sky130_fd_sc_hd__decap_3
XFILLER_35_262 VGND VGND VPWR VPWR sky130_fd_sc_hd__decap_3
XFILLER_23_424 VGND VGND VPWR VPWR sky130_fd_sc_hd__decap_3
X_6824_ _6966_/CLK _6824_/D VGND VGND VPWR VPWR _6824_/Q sky130_fd_sc_hd__dfxtp_2
XTAP_TAPCELL_ROW_18_471 VGND VPWR sky130_fd_sc_hd__tapvpwrvgnd_1
XFILLER_10_107 VGND VGND VPWR VPWR sky130_fd_sc_hd__decap_3
X_6755_ _6977_/CLK _6755_/D VGND VGND VPWR VPWR _6755_/Q sky130_fd_sc_hd__dfxtp_2
XFILLER_10_129 VGND VGND VPWR VPWR sky130_fd_sc_hd__decap_3
X_5706_ _7359_/Q hold950/X _5721_/S VGND VGND VPWR VPWR _6703_/D sky130_fd_sc_hd__mux2_2
Xclkbuf_leaf_30_clk clkbuf_3_2__f_clk/X VGND VGND VPWR VPWR _6972_/CLK sky130_fd_sc_hd__clkbuf_16
X_6686_ _6686_/A VGND VGND VPWR VPWR _6686_/Y sky130_fd_sc_hd__inv_2
X_3898_ _6919_/Q _3926_/A2 _3926_/B1 _6783_/Q VGND VGND VPWR VPWR _3898_/X sky130_fd_sc_hd__a22o_2
XFILLER_12_47 VGND VGND VPWR VPWR sky130_fd_sc_hd__decap_3
X_5568_ hold979/X _4909_/A _4897_/X VGND VGND VPWR VPWR _7049_/D sky130_fd_sc_hd__a21o_2
XFILLER_104_212 VGND VGND VPWR VPWR sky130_fd_sc_hd__decap_3
XFILLER_2_306 VGND VGND VPWR VPWR sky130_fd_sc_hd__fill_2
XFILLER_88_29 VGND VGND VPWR VPWR sky130_fd_sc_hd__decap_3
X_7307_ _7338_/CLK _7307_/D _6587_/Y VGND VGND VPWR VPWR _7307_/Q sky130_fd_sc_hd__dfrtp_2
X_4519_ hold971/X _3398_/Y _4300_/X VGND VGND VPWR VPWR _7320_/D sky130_fd_sc_hd__a21o_2
XFILLER_104_256 VGND VGND VPWR VPWR sky130_fd_sc_hd__decap_3
X_7238_ _7368_/CLK _7238_/D _6518_/Y VGND VGND VPWR VPWR _7238_/Q sky130_fd_sc_hd__dfrtp_2
XFILLER_77_107 VGND VGND VPWR VPWR sky130_fd_sc_hd__decap_3
XFILLER_58_321 VGND VGND VPWR VPWR sky130_fd_sc_hd__decap_3
XFILLER_86_641 VGND VGND VPWR VPWR sky130_fd_sc_hd__decap_3
X_7169_ _7363_/CLK _7169_/D _6449_/Y VGND VGND VPWR VPWR _7169_/Q sky130_fd_sc_hd__dfrtp_2
XFILLER_58_365 VGND VGND VPWR VPWR sky130_fd_sc_hd__decap_3
XFILLER_85_140 VGND VGND VPWR VPWR sky130_fd_sc_hd__decap_3
XFILLER_86_674 VGND VGND VPWR VPWR sky130_fd_sc_hd__decap_3
XFILLER_100_473 VGND VGND VPWR VPWR sky130_fd_sc_hd__decap_3
XFILLER_100_495 VGND VGND VPWR VPWR sky130_fd_sc_hd__decap_3
XFILLER_18_218 VGND VGND VPWR VPWR sky130_fd_sc_hd__decap_3
XFILLER_46_527 VGND VGND VPWR VPWR sky130_fd_sc_hd__decap_3
XFILLER_61_508 VGND VGND VPWR VPWR sky130_fd_sc_hd__decap_3
XFILLER_26_251 VGND VGND VPWR VPWR sky130_fd_sc_hd__fill_1
XFILLER_26_262 VGND VGND VPWR VPWR sky130_fd_sc_hd__decap_3
XFILLER_54_560 VGND VGND VPWR VPWR sky130_fd_sc_hd__decap_3
XFILLER_26_295 VGND VGND VPWR VPWR sky130_fd_sc_hd__fill_1
XFILLER_41_210 VGND VGND VPWR VPWR sky130_fd_sc_hd__fill_2
XFILLER_41_221 VGND VGND VPWR VPWR sky130_fd_sc_hd__decap_3
XFILLER_53_54 VGND VGND VPWR VPWR sky130_fd_sc_hd__fill_2
XFILLER_41_287 VGND VGND VPWR VPWR sky130_fd_sc_hd__decap_3
XFILLER_22_490 VGND VGND VPWR VPWR sky130_fd_sc_hd__fill_2
Xclkbuf_leaf_21_clk clkbuf_3_6__f_clk/X VGND VGND VPWR VPWR _7392_/CLK sky130_fd_sc_hd__clkbuf_16
XFILLER_10_674 VGND VGND VPWR VPWR sky130_fd_sc_hd__fill_2
XFILLER_5_111 VGND VGND VPWR VPWR sky130_fd_sc_hd__fill_1
XFILLER_5_122 VGND VGND VPWR VPWR sky130_fd_sc_hd__decap_3
XFILLER_6_645 VGND VGND VPWR VPWR sky130_fd_sc_hd__decap_3
XFILLER_6_678 VGND VGND VPWR VPWR sky130_fd_sc_hd__decap_3
XFILLER_108_595 VGND VGND VPWR VPWR sky130_fd_sc_hd__decap_3
XFILLER_5_166 VGND VGND VPWR VPWR sky130_fd_sc_hd__fill_2
XFILLER_5_188 VGND VGND VPWR VPWR sky130_fd_sc_hd__decap_3
XTAP_TAPCELL_ROW_114_1624 VGND VPWR sky130_fd_sc_hd__tapvpwrvgnd_1
XFILLER_78_73 VGND VGND VPWR VPWR sky130_fd_sc_hd__decap_3
XFILLER_96_427 VGND VGND VPWR VPWR sky130_fd_sc_hd__decap_3
XFILLER_110_226 VGND VGND VPWR VPWR sky130_fd_sc_hd__decap_3
XFILLER_110_248 VGND VGND VPWR VPWR sky130_fd_sc_hd__decap_3
XFILLER_1_372 VGND VGND VPWR VPWR sky130_fd_sc_hd__decap_3
XFILLER_77_641 VGND VGND VPWR VPWR sky130_fd_sc_hd__decap_3
XFILLER_110_259 VGND VGND VPWR VPWR sky130_fd_sc_hd__decap_3
XFILLER_37_505 VGND VGND VPWR VPWR sky130_fd_sc_hd__decap_3
XFILLER_64_324 VGND VGND VPWR VPWR sky130_fd_sc_hd__decap_3
XFILLER_76_184 VGND VGND VPWR VPWR sky130_fd_sc_hd__decap_3
XFILLER_77_685 VGND VGND VPWR VPWR sky130_fd_sc_hd__decap_3
XFILLER_94_61 VGND VGND VPWR VPWR sky130_fd_sc_hd__decap_3
XFILLER_64_346 VGND VGND VPWR VPWR sky130_fd_sc_hd__decap_3
XFILLER_64_368 VGND VGND VPWR VPWR sky130_fd_sc_hd__decap_3
XFILLER_91_143 VGND VGND VPWR VPWR sky130_fd_sc_hd__decap_3
XFILLER_92_666 VGND VGND VPWR VPWR sky130_fd_sc_hd__decap_3
XFILLER_17_240 VGND VGND VPWR VPWR sky130_fd_sc_hd__decap_3
XFILLER_17_273 VGND VGND VPWR VPWR sky130_fd_sc_hd__decap_3
XFILLER_52_519 VGND VGND VPWR VPWR sky130_fd_sc_hd__decap_3
XFILLER_32_221 VGND VGND VPWR VPWR sky130_fd_sc_hd__decap_3
XFILLER_60_541 VGND VGND VPWR VPWR sky130_fd_sc_hd__decap_3
X_4870_ _4870_/A _4870_/B VGND VGND VPWR VPWR _4870_/Y sky130_fd_sc_hd__nor2_2
XFILLER_32_265 VGND VGND VPWR VPWR sky130_fd_sc_hd__fill_2
X_3821_ _3746_/C _3819_/X _3820_/X _3896_/B1 VGND VGND VPWR VPWR _5010_/C sky130_fd_sc_hd__o31a_2
XTAP_TAPCELL_ROW_15_430 VGND VPWR sky130_fd_sc_hd__tapvpwrvgnd_1
XFILLER_20_416 VGND VGND VPWR VPWR sky130_fd_sc_hd__fill_1
X_6540_ _6540_/A VGND VGND VPWR VPWR _6540_/Y sky130_fd_sc_hd__inv_2
XTAP_TAPCELL_ROW_43_772 VGND VPWR sky130_fd_sc_hd__tapvpwrvgnd_1
Xclkbuf_leaf_12_clk clkload3/A VGND VGND VPWR VPWR _7403_/CLK sky130_fd_sc_hd__clkbuf_16
X_3752_ _6799_/Q _3862_/B1 _3767_/A2 _6709_/Q _3751_/X VGND VGND VPWR VPWR _3752_/X
+ sky130_fd_sc_hd__a221o_2
X_6471_ _6634_/A VGND VGND VPWR VPWR _6471_/Y sky130_fd_sc_hd__inv_2
X_3683_ _3672_/X _3673_/X _3896_/B1 _3682_/Y VGND VGND VPWR VPWR _3683_/Y sky130_fd_sc_hd__o211ai_2
XFILLER_9_472 VGND VGND VPWR VPWR sky130_fd_sc_hd__fill_1
XFILLER_114_510 VGND VGND VPWR VPWR sky130_fd_sc_hd__decap_3
XFILLER_114_554 VGND VGND VPWR VPWR sky130_fd_sc_hd__decap_3
X_4304_ _7256_/Q _4601_/S _4303_/X VGND VGND VPWR VPWR _4364_/A sky130_fd_sc_hd__a21oi_2
XFILLER_99_254 VGND VGND VPWR VPWR sky130_fd_sc_hd__decap_3
XFILLER_114_587 VGND VGND VPWR VPWR sky130_fd_sc_hd__fill_1
XFILLER_59_107 VGND VGND VPWR VPWR sky130_fd_sc_hd__fill_1
XFILLER_87_427 VGND VGND VPWR VPWR sky130_fd_sc_hd__decap_3
X_5284_ _5284_/A0 _5135_/X _5292_/S VGND VGND VPWR VPWR _7187_/D sky130_fd_sc_hd__mux2_2
XFILLER_99_287 VGND VGND VPWR VPWR sky130_fd_sc_hd__decap_3
XFILLER_114_598 VGND VGND VPWR VPWR sky130_fd_sc_hd__decap_3
XFILLER_59_129 VGND VGND VPWR VPWR sky130_fd_sc_hd__decap_3
XFILLER_87_449 VGND VGND VPWR VPWR sky130_fd_sc_hd__fill_1
X_7023_ _7267_/CLK _7023_/D _6303_/Y VGND VGND VPWR VPWR _7023_/Q sky130_fd_sc_hd__dfrtp_2
X_4235_ _7227_/Q _4340_/A2 _4235_/B1 _7131_/Q VGND VGND VPWR VPWR _4235_/X sky130_fd_sc_hd__a22o_2
XFILLER_114_27 VGND VGND VPWR VPWR sky130_fd_sc_hd__fill_1
XFILLER_114_38 VGND VGND VPWR VPWR sky130_fd_sc_hd__decap_3
X_4166_ _7233_/Q _3318_/B _3962_/S _7201_/Q VGND VGND VPWR VPWR _4166_/X sky130_fd_sc_hd__a22o_2
XFILLER_55_302 VGND VGND VPWR VPWR sky130_fd_sc_hd__decap_3
XFILLER_55_324 VGND VGND VPWR VPWR sky130_fd_sc_hd__decap_3
XFILLER_95_482 VGND VGND VPWR VPWR sky130_fd_sc_hd__decap_3
XFILLER_55_346 VGND VGND VPWR VPWR sky130_fd_sc_hd__decap_3
XFILLER_67_195 VGND VGND VPWR VPWR sky130_fd_sc_hd__decap_3
XFILLER_82_121 VGND VGND VPWR VPWR sky130_fd_sc_hd__decap_3
XFILLER_83_644 VGND VGND VPWR VPWR sky130_fd_sc_hd__fill_2
XFILLER_83_666 VGND VGND VPWR VPWR sky130_fd_sc_hd__decap_3
XFILLER_55_379 VGND VGND VPWR VPWR sky130_fd_sc_hd__decap_3
XFILLER_11_405 VGND VGND VPWR VPWR sky130_fd_sc_hd__decap_3
XFILLER_23_265 VGND VGND VPWR VPWR sky130_fd_sc_hd__decap_3
Xplace390 _5666_/A VGND VGND VPWR VPWR _5640_/A sky130_fd_sc_hd__buf_2
X_6807_ _7005_/CLK _6807_/D VGND VGND VPWR VPWR _6807_/Q sky130_fd_sc_hd__dfxtp_2
XFILLER_23_24 VGND VGND VPWR VPWR sky130_fd_sc_hd__decap_3
XFILLER_23_287 VGND VGND VPWR VPWR sky130_fd_sc_hd__decap_3
XFILLER_23_57 VGND VGND VPWR VPWR sky130_fd_sc_hd__decap_3
X_6738_ _6911_/CLK _6738_/D VGND VGND VPWR VPWR _6738_/Q sky130_fd_sc_hd__dfxtp_2
XFILLER_109_337 VGND VGND VPWR VPWR sky130_fd_sc_hd__fill_2
XFILLER_109_348 VGND VGND VPWR VPWR sky130_fd_sc_hd__fill_2
X_6669_ _6672_/A VGND VGND VPWR VPWR _6669_/Y sky130_fd_sc_hd__inv_2
XTAP_TAPCELL_ROW_21_499 VGND VPWR sky130_fd_sc_hd__tapvpwrvgnd_1
XFILLER_99_39 VGND VGND VPWR VPWR sky130_fd_sc_hd__fill_1
XFILLER_2_103 VGND VGND VPWR VPWR sky130_fd_sc_hd__decap_3
XFILLER_3_615 VGND VGND VPWR VPWR sky130_fd_sc_hd__fill_1
XFILLER_3_626 VGND VGND VPWR VPWR sky130_fd_sc_hd__decap_3
XFILLER_105_543 VGND VGND VPWR VPWR sky130_fd_sc_hd__decap_3
XFILLER_2_136 VGND VGND VPWR VPWR sky130_fd_sc_hd__decap_3
XFILLER_2_147 VGND VGND VPWR VPWR sky130_fd_sc_hd__decap_3
XFILLER_3_659 VGND VGND VPWR VPWR sky130_fd_sc_hd__decap_3
XFILLER_78_427 VGND VGND VPWR VPWR sky130_fd_sc_hd__decap_3
XFILLER_48_10 VGND VGND VPWR VPWR sky130_fd_sc_hd__decap_3
XFILLER_59_641 VGND VGND VPWR VPWR sky130_fd_sc_hd__decap_3
XFILLER_48_65 VGND VGND VPWR VPWR sky130_fd_sc_hd__decap_3
XFILLER_86_460 VGND VGND VPWR VPWR sky130_fd_sc_hd__decap_3
XFILLER_93_419 VGND VGND VPWR VPWR sky130_fd_sc_hd__decap_3
XFILLER_0_17 VGND VGND VPWR VPWR sky130_fd_sc_hd__decap_3
XFILLER_58_162 VGND VGND VPWR VPWR sky130_fd_sc_hd__decap_3
XFILLER_59_685 VGND VGND VPWR VPWR sky130_fd_sc_hd__decap_3
XFILLER_73_110 VGND VGND VPWR VPWR sky130_fd_sc_hd__fill_2
XFILLER_100_281 VGND VGND VPWR VPWR sky130_fd_sc_hd__decap_3
XFILLER_46_335 VGND VGND VPWR VPWR sky130_fd_sc_hd__decap_3
XFILLER_46_357 VGND VGND VPWR VPWR sky130_fd_sc_hd__fill_2
XFILLER_58_195 VGND VGND VPWR VPWR sky130_fd_sc_hd__fill_1
XFILLER_61_305 VGND VGND VPWR VPWR sky130_fd_sc_hd__decap_3
XFILLER_14_221 VGND VGND VPWR VPWR sky130_fd_sc_hd__decap_3
XFILLER_27_582 VGND VGND VPWR VPWR sky130_fd_sc_hd__decap_3
XFILLER_42_530 VGND VGND VPWR VPWR sky130_fd_sc_hd__fill_2
XFILLER_73_198 VGND VGND VPWR VPWR sky130_fd_sc_hd__decap_3
XTAP_TAPCELL_ROW_64_1022 VGND VPWR sky130_fd_sc_hd__tapvpwrvgnd_1
XTAP_TAPCELL_ROW_29_599 VGND VPWR sky130_fd_sc_hd__tapvpwrvgnd_1
XFILLER_42_541 VGND VGND VPWR VPWR sky130_fd_sc_hd__decap_3
XFILLER_9_15 VGND VGND VPWR VPWR sky130_fd_sc_hd__decap_3
XFILLER_14_287 VGND VGND VPWR VPWR sky130_fd_sc_hd__decap_3
XFILLER_80_41 VGND VGND VPWR VPWR sky130_fd_sc_hd__decap_3
XTAP_TAPCELL_ROW_12_400 VGND VPWR sky130_fd_sc_hd__tapvpwrvgnd_1
XFILLER_9_48 VGND VGND VPWR VPWR sky130_fd_sc_hd__decap_3
XFILLER_80_74 VGND VGND VPWR VPWR sky130_fd_sc_hd__fill_1
XTAP_TAPCELL_ROW_40_731 VGND VPWR sky130_fd_sc_hd__tapvpwrvgnd_1
XFILLER_80_85 VGND VGND VPWR VPWR sky130_fd_sc_hd__decap_3
XFILLER_10_493 VGND VGND VPWR VPWR sky130_fd_sc_hd__fill_2
XFILLER_13_90 VGND VGND VPWR VPWR sky130_fd_sc_hd__fill_1
XFILLER_89_72 VGND VGND VPWR VPWR sky130_fd_sc_hd__fill_2
XTAP_TAPCELL_ROW_75_1151 VGND VPWR sky130_fd_sc_hd__tapvpwrvgnd_1
XFILLER_69_427 VGND VGND VPWR VPWR sky130_fd_sc_hd__fill_2
XFILLER_111_535 VGND VGND VPWR VPWR sky130_fd_sc_hd__decap_3
XFILLER_2_681 VGND VGND VPWR VPWR sky130_fd_sc_hd__decap_3
XFILLER_96_246 VGND VGND VPWR VPWR sky130_fd_sc_hd__decap_3
Xclkbuf_leaf_1_clk clkload0/A VGND VGND VPWR VPWR _7279_/CLK sky130_fd_sc_hd__clkbuf_16
X_4020_ _7086_/Q _4432_/A2 _4142_/A _4019_/X VGND VGND VPWR VPWR _4039_/A sky130_fd_sc_hd__o211ai_2
XFILLER_65_611 VGND VGND VPWR VPWR sky130_fd_sc_hd__decap_3
XFILLER_77_482 VGND VGND VPWR VPWR sky130_fd_sc_hd__decap_3
XFILLER_49_195 VGND VGND VPWR VPWR sky130_fd_sc_hd__fill_2
XFILLER_64_121 VGND VGND VPWR VPWR sky130_fd_sc_hd__decap_3
XFILLER_65_644 VGND VGND VPWR VPWR sky130_fd_sc_hd__decap_3
XTAP_TAPCELL_ROW_48_831 VGND VPWR sky130_fd_sc_hd__tapvpwrvgnd_1
XFILLER_25_508 VGND VGND VPWR VPWR sky130_fd_sc_hd__decap_3
XFILLER_65_688 VGND VGND VPWR VPWR sky130_fd_sc_hd__decap_3
XFILLER_80_603 VGND VGND VPWR VPWR sky130_fd_sc_hd__decap_3
XFILLER_52_327 VGND VGND VPWR VPWR sky130_fd_sc_hd__decap_3
XFILLER_64_187 VGND VGND VPWR VPWR sky130_fd_sc_hd__decap_3
XFILLER_80_636 VGND VGND VPWR VPWR sky130_fd_sc_hd__decap_3
XFILLER_80_669 VGND VGND VPWR VPWR sky130_fd_sc_hd__decap_3
X_4922_ _4937_/A _4937_/B _4203_/X VGND VGND VPWR VPWR _4922_/X sky130_fd_sc_hd__a21o_2
XTAP_TAPCELL_ROW_86_1280 VGND VPWR sky130_fd_sc_hd__tapvpwrvgnd_1
XFILLER_100_18 VGND VGND VPWR VPWR sky130_fd_sc_hd__decap_3
XFILLER_100_29 VGND VGND VPWR VPWR sky130_fd_sc_hd__decap_3
XFILLER_20_224 VGND VGND VPWR VPWR sky130_fd_sc_hd__decap_3
XFILLER_60_371 VGND VGND VPWR VPWR sky130_fd_sc_hd__decap_3
X_4784_ _4813_/A _4829_/B VGND VGND VPWR VPWR _4811_/B sky130_fd_sc_hd__nand2_2
X_3804_ _6826_/Q _3879_/A2 _3878_/A2 _6811_/Q _3803_/X VGND VGND VPWR VPWR _3804_/X
+ sky130_fd_sc_hd__a221o_2
X_6523_ _6523_/A VGND VGND VPWR VPWR _6523_/Y sky130_fd_sc_hd__inv_2
X_3735_ _3735_/A _3746_/B _3746_/C VGND VGND VPWR VPWR _3735_/X sky130_fd_sc_hd__and3_4
XFILLER_109_27 VGND VGND VPWR VPWR sky130_fd_sc_hd__decap_3
X_6454_ _6675_/A VGND VGND VPWR VPWR _6454_/Y sky130_fd_sc_hd__inv_2
X_6385_ _6385_/A VGND VGND VPWR VPWR _6385_/Y sky130_fd_sc_hd__inv_2
X_3597_ _4295_/B _3607_/B VGND VGND VPWR VPWR _3611_/B sky130_fd_sc_hd__nor2_2
XFILLER_0_629 VGND VGND VPWR VPWR sky130_fd_sc_hd__fill_1
XFILLER_114_362 VGND VGND VPWR VPWR sky130_fd_sc_hd__fill_2
X_5336_ _5336_/A0 _5040_/X _5360_/S VGND VGND VPWR VPWR _7163_/D sky130_fd_sc_hd__mux2_2
XFILLER_75_408 VGND VGND VPWR VPWR sky130_fd_sc_hd__decap_3
XFILLER_87_246 VGND VGND VPWR VPWR sky130_fd_sc_hd__decap_3
XFILLER_87_279 VGND VGND VPWR VPWR sky130_fd_sc_hd__fill_1
X_7006_ _7341_/CLK _7006_/D _6286_/Y VGND VGND VPWR VPWR _7006_/Q sky130_fd_sc_hd__dfrtp_2
X_4218_ _7100_/Q _4351_/A2 _4351_/B1 _7132_/Q VGND VGND VPWR VPWR _4218_/X sky130_fd_sc_hd__a22o_2
XFILLER_18_24 VGND VGND VPWR VPWR sky130_fd_sc_hd__decap_3
XFILLER_18_35 VGND VGND VPWR VPWR sky130_fd_sc_hd__decap_3
XFILLER_56_600 VGND VGND VPWR VPWR sky130_fd_sc_hd__decap_3
XFILLER_56_633 VGND VGND VPWR VPWR sky130_fd_sc_hd__decap_3
X_5198_ _5198_/A _5217_/B VGND VGND VPWR VPWR _7229_/D sky130_fd_sc_hd__and2_2
XFILLER_18_68 VGND VGND VPWR VPWR sky130_fd_sc_hd__decap_3
XFILLER_55_143 VGND VGND VPWR VPWR sky130_fd_sc_hd__decap_3
XFILLER_56_666 VGND VGND VPWR VPWR sky130_fd_sc_hd__decap_3
XFILLER_83_452 VGND VGND VPWR VPWR sky130_fd_sc_hd__decap_3
X_4149_ _4205_/A _4205_/B VGND VGND VPWR VPWR _4157_/A sky130_fd_sc_hd__nand2_2
XFILLER_71_603 VGND VGND VPWR VPWR sky130_fd_sc_hd__decap_3
XFILLER_55_198 VGND VGND VPWR VPWR sky130_fd_sc_hd__decap_3
XFILLER_71_647 VGND VGND VPWR VPWR sky130_fd_sc_hd__decap_3
XFILLER_83_496 VGND VGND VPWR VPWR sky130_fd_sc_hd__decap_3
XFILLER_34_23 VGND VGND VPWR VPWR sky130_fd_sc_hd__decap_3
XFILLER_34_45 VGND VGND VPWR VPWR sky130_fd_sc_hd__decap_3
XTAP_TAPCELL_ROW_26_569 VGND VPWR sky130_fd_sc_hd__tapvpwrvgnd_1
XTAP_TAPCELL_ROW_26_558 VGND VPWR sky130_fd_sc_hd__tapvpwrvgnd_1
XFILLER_11_246 VGND VGND VPWR VPWR sky130_fd_sc_hd__fill_2
XFILLER_51_393 VGND VGND VPWR VPWR sky130_fd_sc_hd__decap_3
XFILLER_50_11 VGND VGND VPWR VPWR sky130_fd_sc_hd__fill_1
XFILLER_50_22 VGND VGND VPWR VPWR sky130_fd_sc_hd__decap_3
XFILLER_7_206 VGND VGND VPWR VPWR sky130_fd_sc_hd__decap_3
XFILLER_7_228 VGND VGND VPWR VPWR sky130_fd_sc_hd__decap_3
Xclkload0 clkload0/A VGND VGND VPWR VPWR clkload0/X sky130_fd_sc_hd__clkbuf_16
XFILLER_50_88 VGND VGND VPWR VPWR sky130_fd_sc_hd__decap_3
XFILLER_3_423 VGND VGND VPWR VPWR sky130_fd_sc_hd__decap_3
XFILLER_3_478 VGND VGND VPWR VPWR sky130_fd_sc_hd__decap_3
XFILLER_59_20 VGND VGND VPWR VPWR sky130_fd_sc_hd__decap_3
XFILLER_59_42 VGND VGND VPWR VPWR sky130_fd_sc_hd__decap_3
XFILLER_105_373 VGND VGND VPWR VPWR sky130_fd_sc_hd__decap_3
XFILLER_115_81 VGND VGND VPWR VPWR sky130_fd_sc_hd__decap_3
XFILLER_47_611 VGND VGND VPWR VPWR sky130_fd_sc_hd__decap_3
XFILLER_93_216 VGND VGND VPWR VPWR sky130_fd_sc_hd__decap_3
XTAP_TAPCELL_ROW_70_1092 VGND VPWR sky130_fd_sc_hd__tapvpwrvgnd_1
XFILLER_19_324 VGND VGND VPWR VPWR sky130_fd_sc_hd__decap_3
XFILLER_47_644 VGND VGND VPWR VPWR sky130_fd_sc_hd__decap_3
XFILLER_75_52 VGND VGND VPWR VPWR sky130_fd_sc_hd__decap_3
XFILLER_75_63 VGND VGND VPWR VPWR sky130_fd_sc_hd__decap_3
XFILLER_34_305 VGND VGND VPWR VPWR sky130_fd_sc_hd__decap_3
XFILLER_47_688 VGND VGND VPWR VPWR sky130_fd_sc_hd__decap_3
XFILLER_62_614 VGND VGND VPWR VPWR sky130_fd_sc_hd__decap_3
XFILLER_75_96 VGND VGND VPWR VPWR sky130_fd_sc_hd__decap_3
XTAP_TAPCELL_ROW_109_1556 VGND VPWR sky130_fd_sc_hd__tapvpwrvgnd_1
XFILLER_61_113 VGND VGND VPWR VPWR sky130_fd_sc_hd__decap_3
XFILLER_61_135 VGND VGND VPWR VPWR sky130_fd_sc_hd__decap_3
XFILLER_62_669 VGND VGND VPWR VPWR sky130_fd_sc_hd__decap_3
XFILLER_15_596 VGND VGND VPWR VPWR sky130_fd_sc_hd__fill_2
XFILLER_70_691 VGND VGND VPWR VPWR sky130_fd_sc_hd__fill_1
XFILLER_30_533 VGND VGND VPWR VPWR sky130_fd_sc_hd__fill_1
X_3520_ _5118_/D _3354_/X _3519_/Y _3350_/B VGND VGND VPWR VPWR _3525_/B sky130_fd_sc_hd__o2bb2a_2
XFILLER_116_638 VGND VGND VPWR VPWR sky130_fd_sc_hd__decap_3
Xhold707 _6964_/Q VGND VGND VPWR VPWR _6964_/D sky130_fd_sc_hd__dlygate4sd3_1
Xhold718 _6965_/Q VGND VGND VPWR VPWR _6965_/D sky130_fd_sc_hd__dlygate4sd3_1
XFILLER_115_137 VGND VGND VPWR VPWR sky130_fd_sc_hd__decap_3
XFILLER_6_283 VGND VGND VPWR VPWR sky130_fd_sc_hd__decap_3
Xhold729 _6953_/Q VGND VGND VPWR VPWR _6953_/D sky130_fd_sc_hd__dlygate4sd3_1
XFILLER_69_202 VGND VGND VPWR VPWR sky130_fd_sc_hd__decap_3
XFILLER_97_511 VGND VGND VPWR VPWR sky130_fd_sc_hd__decap_3
X_5121_ _5092_/C _5117_/X _5118_/X _6984_/D _5666_/A VGND VGND VPWR VPWR _5121_/X
+ sky130_fd_sc_hd__a32o_2
XFILLER_111_343 VGND VGND VPWR VPWR sky130_fd_sc_hd__decap_3
XFILLER_69_246 VGND VGND VPWR VPWR sky130_fd_sc_hd__decap_3
XFILLER_69_257 VGND VGND VPWR VPWR sky130_fd_sc_hd__decap_3
XFILLER_111_376 VGND VGND VPWR VPWR sky130_fd_sc_hd__decap_3
XFILLER_111_387 VGND VGND VPWR VPWR sky130_fd_sc_hd__fill_2
XFILLER_84_227 VGND VGND VPWR VPWR sky130_fd_sc_hd__decap_3
X_5052_ _3548_/X _5049_/X _5051_/X _3618_/X VGND VGND VPWR VPWR _5052_/X sky130_fd_sc_hd__a2bb2o_2
XFILLER_37_110 VGND VGND VPWR VPWR sky130_fd_sc_hd__fill_2
XFILLER_37_132 VGND VGND VPWR VPWR sky130_fd_sc_hd__fill_1
XFILLER_65_441 VGND VGND VPWR VPWR sky130_fd_sc_hd__decap_3
XFILLER_1_60 VGND VGND VPWR VPWR sky130_fd_sc_hd__decap_3
XFILLER_37_143 VGND VGND VPWR VPWR sky130_fd_sc_hd__fill_1
XFILLER_38_677 VGND VGND VPWR VPWR sky130_fd_sc_hd__decap_3
XFILLER_65_452 VGND VGND VPWR VPWR sky130_fd_sc_hd__decap_3
XFILLER_65_463 VGND VGND VPWR VPWR sky130_fd_sc_hd__decap_3
XFILLER_111_28 VGND VGND VPWR VPWR sky130_fd_sc_hd__decap_3
XFILLER_1_93 VGND VGND VPWR VPWR sky130_fd_sc_hd__decap_3
XFILLER_25_349 VGND VGND VPWR VPWR sky130_fd_sc_hd__decap_3
XFILLER_37_187 VGND VGND VPWR VPWR sky130_fd_sc_hd__decap_3
XFILLER_53_647 VGND VGND VPWR VPWR sky130_fd_sc_hd__fill_1
XFILLER_92_271 VGND VGND VPWR VPWR sky130_fd_sc_hd__decap_3
XFILLER_52_168 VGND VGND VPWR VPWR sky130_fd_sc_hd__decap_3
XFILLER_80_444 VGND VGND VPWR VPWR sky130_fd_sc_hd__fill_1
XFILLER_80_477 VGND VGND VPWR VPWR sky130_fd_sc_hd__decap_3
XFILLER_21_522 VGND VGND VPWR VPWR sky130_fd_sc_hd__fill_2
XFILLER_61_691 VGND VGND VPWR VPWR sky130_fd_sc_hd__fill_1
X_4905_ _3526_/B _4888_/A _4903_/A _5101_/A VGND VGND VPWR VPWR _4905_/X sky130_fd_sc_hd__o2bb2a_2
XTAP_TAPCELL_ROW_23_528 VGND VPWR sky130_fd_sc_hd__tapvpwrvgnd_1
XFILLER_21_544 VGND VGND VPWR VPWR sky130_fd_sc_hd__decap_3
XFILLER_21_555 VGND VGND VPWR VPWR sky130_fd_sc_hd__decap_3
X_4836_ _7001_/D _4835_/X _4836_/S VGND VGND VPWR VPWR _4836_/X sky130_fd_sc_hd__mux2_2
XTAP_TAPCELL_ROW_51_859 VGND VPWR sky130_fd_sc_hd__tapvpwrvgnd_1
X_6506_ _6535_/A VGND VGND VPWR VPWR _6506_/Y sky130_fd_sc_hd__inv_2
X_4767_ _5057_/A _4452_/A _4453_/A _4852_/A _4766_/Y VGND VGND VPWR VPWR _4767_/X
+ sky130_fd_sc_hd__o221a_2
XFILLER_106_115 VGND VGND VPWR VPWR sky130_fd_sc_hd__fill_1
XFILLER_107_638 VGND VGND VPWR VPWR sky130_fd_sc_hd__decap_3
XFILLER_4_209 VGND VGND VPWR VPWR sky130_fd_sc_hd__decap_3
X_4698_ _6985_/Q _5120_/A VGND VGND VPWR VPWR _5098_/A sky130_fd_sc_hd__and2_2
XFILLER_106_126 VGND VGND VPWR VPWR sky130_fd_sc_hd__decap_3
XFILLER_20_47 VGND VGND VPWR VPWR sky130_fd_sc_hd__decap_3
X_6437_ _6570_/A VGND VGND VPWR VPWR _6437_/Y sky130_fd_sc_hd__inv_2
XFILLER_115_671 VGND VGND VPWR VPWR sky130_fd_sc_hd__fill_1
X_6368_ _6567_/A VGND VGND VPWR VPWR _6368_/Y sky130_fd_sc_hd__inv_2
XFILLER_0_415 VGND VGND VPWR VPWR sky130_fd_sc_hd__decap_3
XFILLER_115_682 VGND VGND VPWR VPWR sky130_fd_sc_hd__fill_2
XFILLER_96_29 VGND VGND VPWR VPWR sky130_fd_sc_hd__decap_3
X_5319_ _5319_/A0 _4913_/X _5323_/S VGND VGND VPWR VPWR _7171_/D sky130_fd_sc_hd__mux2_2
XFILLER_102_332 VGND VGND VPWR VPWR sky130_fd_sc_hd__decap_3
XFILLER_114_192 VGND VGND VPWR VPWR sky130_fd_sc_hd__decap_3
XFILLER_29_12 VGND VGND VPWR VPWR sky130_fd_sc_hd__decap_3
XFILLER_88_577 VGND VGND VPWR VPWR sky130_fd_sc_hd__fill_2
X_6299_ _6366_/A VGND VGND VPWR VPWR _6299_/Y sky130_fd_sc_hd__inv_2
XFILLER_102_365 VGND VGND VPWR VPWR sky130_fd_sc_hd__decap_3
XFILLER_29_45 VGND VGND VPWR VPWR sky130_fd_sc_hd__fill_2
XFILLER_48_419 VGND VGND VPWR VPWR sky130_fd_sc_hd__fill_1
XFILLER_28_121 VGND VGND VPWR VPWR sky130_fd_sc_hd__decap_3
XFILLER_28_132 VGND VGND VPWR VPWR sky130_fd_sc_hd__decap_3
XFILLER_75_249 VGND VGND VPWR VPWR sky130_fd_sc_hd__fill_2
XTAP_TAPCELL_ROW_59_959 VGND VPWR sky130_fd_sc_hd__tapvpwrvgnd_1
XFILLER_28_165 VGND VGND VPWR VPWR sky130_fd_sc_hd__decap_3
XFILLER_45_11 VGND VGND VPWR VPWR sky130_fd_sc_hd__fill_1
XFILLER_56_463 VGND VGND VPWR VPWR sky130_fd_sc_hd__decap_3
XFILLER_90_219 VGND VGND VPWR VPWR sky130_fd_sc_hd__decap_3
XTAP_TAPCELL_ROW_3_286 VGND VPWR sky130_fd_sc_hd__tapvpwrvgnd_1
XFILLER_16_327 VGND VGND VPWR VPWR sky130_fd_sc_hd__decap_3
XFILLER_43_102 VGND VGND VPWR VPWR sky130_fd_sc_hd__fill_2
XFILLER_43_113 VGND VGND VPWR VPWR sky130_fd_sc_hd__decap_3
XFILLER_44_636 VGND VGND VPWR VPWR sky130_fd_sc_hd__decap_3
XFILLER_45_33 VGND VGND VPWR VPWR sky130_fd_sc_hd__decap_3
XFILLER_71_411 VGND VGND VPWR VPWR sky130_fd_sc_hd__decap_3
XFILLER_71_433 VGND VGND VPWR VPWR sky130_fd_sc_hd__decap_3
XFILLER_83_271 VGND VGND VPWR VPWR sky130_fd_sc_hd__decap_3
XFILLER_43_146 VGND VGND VPWR VPWR sky130_fd_sc_hd__fill_1
XFILLER_44_669 VGND VGND VPWR VPWR sky130_fd_sc_hd__decap_3
XFILLER_71_455 VGND VGND VPWR VPWR sky130_fd_sc_hd__decap_3
XFILLER_71_466 VGND VGND VPWR VPWR sky130_fd_sc_hd__decap_3
XFILLER_101_72 VGND VGND VPWR VPWR sky130_fd_sc_hd__decap_3
XFILLER_61_43 VGND VGND VPWR VPWR sky130_fd_sc_hd__decap_3
XTAP_TAPCELL_ROW_104_1497 VGND VPWR sky130_fd_sc_hd__tapvpwrvgnd_1
XFILLER_61_87 VGND VGND VPWR VPWR sky130_fd_sc_hd__decap_3
XFILLER_6_27 VGND VGND VPWR VPWR sky130_fd_sc_hd__fill_1
XFILLER_6_38 VGND VGND VPWR VPWR sky130_fd_sc_hd__decap_3
XFILLER_106_660 VGND VGND VPWR VPWR sky130_fd_sc_hd__decap_3
XFILLER_3_231 VGND VGND VPWR VPWR sky130_fd_sc_hd__decap_3
XTAP_TAPCELL_ROW_72_1110 VGND VPWR sky130_fd_sc_hd__tapvpwrvgnd_1
XFILLER_10_80 VGND VGND VPWR VPWR sky130_fd_sc_hd__decap_3
XFILLER_112_118 VGND VGND VPWR VPWR sky130_fd_sc_hd__decap_3
XTAP_TAPCELL_ROW_72_1121 VGND VPWR sky130_fd_sc_hd__tapvpwrvgnd_1
XFILLER_86_73 VGND VGND VPWR VPWR sky130_fd_sc_hd__decap_3
XFILLER_94_514 VGND VGND VPWR VPWR sky130_fd_sc_hd__decap_3
XFILLER_66_249 VGND VGND VPWR VPWR sky130_fd_sc_hd__decap_3
XFILLER_94_569 VGND VGND VPWR VPWR sky130_fd_sc_hd__decap_3
XFILLER_19_165 VGND VGND VPWR VPWR sky130_fd_sc_hd__decap_3
XFILLER_62_400 VGND VGND VPWR VPWR sky130_fd_sc_hd__decap_3
XFILLER_19_187 VGND VGND VPWR VPWR sky130_fd_sc_hd__decap_3
XFILLER_35_636 VGND VGND VPWR VPWR sky130_fd_sc_hd__decap_3
XFILLER_62_433 VGND VGND VPWR VPWR sky130_fd_sc_hd__decap_3
XFILLER_74_271 VGND VGND VPWR VPWR sky130_fd_sc_hd__decap_3
XFILLER_50_606 VGND VGND VPWR VPWR sky130_fd_sc_hd__decap_3
XFILLER_22_319 VGND VGND VPWR VPWR sky130_fd_sc_hd__decap_3
XFILLER_34_168 VGND VGND VPWR VPWR sky130_fd_sc_hd__decap_3
XFILLER_50_639 VGND VGND VPWR VPWR sky130_fd_sc_hd__decap_3
XFILLER_62_477 VGND VGND VPWR VPWR sky130_fd_sc_hd__fill_1
XTAP_TAPCELL_ROW_83_1250 VGND VPWR sky130_fd_sc_hd__tapvpwrvgnd_1
X_5670_ _5670_/A _5670_/B VGND VGND VPWR VPWR _5671_/B sky130_fd_sc_hd__nand2_2
XFILLER_30_341 VGND VGND VPWR VPWR sky130_fd_sc_hd__fill_1
XFILLER_30_363 VGND VGND VPWR VPWR sky130_fd_sc_hd__fill_1
XFILLER_89_3 VGND VGND VPWR VPWR sky130_fd_sc_hd__fill_2
X_4621_ _4315_/B _4343_/X _4315_/A VGND VGND VPWR VPWR _4621_/X sky130_fd_sc_hd__a21bo_2
XFILLER_116_402 VGND VGND VPWR VPWR sky130_fd_sc_hd__decap_3
X_7340_ _7372_/CLK _7340_/D _6620_/Y VGND VGND VPWR VPWR _7340_/Q sky130_fd_sc_hd__dfrtp_2
X_4552_ _4552_/A _4567_/B VGND VGND VPWR VPWR _7304_/D sky130_fd_sc_hd__and2_2
XFILLER_116_424 VGND VGND VPWR VPWR sky130_fd_sc_hd__decap_3
XFILLER_116_446 VGND VGND VPWR VPWR sky130_fd_sc_hd__fill_2
X_7271_ _7369_/CLK _7271_/D _6551_/Y VGND VGND VPWR VPWR _7271_/Q sky130_fd_sc_hd__dfrtp_2
X_3503_ _3545_/A _3545_/B VGND VGND VPWR VPWR _3630_/A sky130_fd_sc_hd__xor2_4
X_3434_ _7218_/Q _4340_/A2 _4235_/B1 _7122_/Q VGND VGND VPWR VPWR _3434_/X sky130_fd_sc_hd__a22o_2
XFILLER_103_107 VGND VGND VPWR VPWR sky130_fd_sc_hd__decap_3
XFILLER_103_129 VGND VGND VPWR VPWR sky130_fd_sc_hd__decap_3
XFILLER_112_663 VGND VGND VPWR VPWR sky130_fd_sc_hd__decap_3
XFILLER_97_330 VGND VGND VPWR VPWR sky130_fd_sc_hd__decap_3
X_3365_ _3365_/A VGND VGND VPWR VPWR _5118_/A sky130_fd_sc_hd__inv_2
XFILLER_111_140 VGND VGND VPWR VPWR sky130_fd_sc_hd__decap_3
XFILLER_111_162 VGND VGND VPWR VPWR sky130_fd_sc_hd__decap_3
XFILLER_85_503 VGND VGND VPWR VPWR sky130_fd_sc_hd__fill_1
XFILLER_97_385 VGND VGND VPWR VPWR sky130_fd_sc_hd__decap_3
Xhold1204 _7120_/Q VGND VGND VPWR VPWR _5427_/A0 sky130_fd_sc_hd__dlygate4sd3_1
Xhold1215 _7169_/Q VGND VGND VPWR VPWR _5323_/A0 sky130_fd_sc_hd__dlygate4sd3_1
X_5104_ _5104_/A _5660_/C VGND VGND VPWR VPWR _5104_/Y sky130_fd_sc_hd__nand2_2
XFILLER_111_184 VGND VGND VPWR VPWR sky130_fd_sc_hd__fill_1
XFILLER_85_547 VGND VGND VPWR VPWR sky130_fd_sc_hd__fill_2
XFILLER_85_558 VGND VGND VPWR VPWR sky130_fd_sc_hd__fill_2
XFILLER_97_396 VGND VGND VPWR VPWR sky130_fd_sc_hd__decap_3
XFILLER_72_208 VGND VGND VPWR VPWR sky130_fd_sc_hd__fill_1
XTAP_TAPCELL_ROW_56_929 VGND VPWR sky130_fd_sc_hd__tapvpwrvgnd_1
XTAP_TAPCELL_ROW_56_918 VGND VPWR sky130_fd_sc_hd__tapvpwrvgnd_1
XFILLER_25_102 VGND VGND VPWR VPWR sky130_fd_sc_hd__decap_3
XFILLER_65_271 VGND VGND VPWR VPWR sky130_fd_sc_hd__decap_3
XFILLER_65_293 VGND VGND VPWR VPWR sky130_fd_sc_hd__decap_3
XFILLER_93_580 VGND VGND VPWR VPWR sky130_fd_sc_hd__decap_3
XTAP_TAPCELL_ROW_0_245 VGND VPWR sky130_fd_sc_hd__tapvpwrvgnd_1
XTAP_TAPCELL_ROW_0_234 VGND VPWR sky130_fd_sc_hd__tapvpwrvgnd_1
XFILLER_25_146 VGND VGND VPWR VPWR sky130_fd_sc_hd__decap_3
XFILLER_41_606 VGND VGND VPWR VPWR sky130_fd_sc_hd__decap_3
X_6986_ _7401_/CLK _6986_/D _6266_/Y VGND VGND VPWR VPWR _6986_/Q sky130_fd_sc_hd__dfrtp_2
XTAP_TAPCELL_ROW_0_256 VGND VPWR sky130_fd_sc_hd__tapvpwrvgnd_1
XFILLER_15_36 VGND VGND VPWR VPWR sky130_fd_sc_hd__decap_3
XFILLER_41_617 VGND VGND VPWR VPWR sky130_fd_sc_hd__fill_2
XFILLER_53_499 VGND VGND VPWR VPWR sky130_fd_sc_hd__decap_3
XTAP_TAPCELL_ROW_36_686 VGND VPWR sky130_fd_sc_hd__tapvpwrvgnd_1
XFILLER_33_190 VGND VGND VPWR VPWR sky130_fd_sc_hd__decap_3
XFILLER_80_296 VGND VGND VPWR VPWR sky130_fd_sc_hd__decap_3
XFILLER_21_341 VGND VGND VPWR VPWR sky130_fd_sc_hd__decap_3
X_4819_ _7002_/Q _4834_/A _4818_/Y _4777_/A VGND VGND VPWR VPWR _4819_/X sky130_fd_sc_hd__o211a_2
XTAP_TAPCELL_ROW_97_1419 VGND VPWR sky130_fd_sc_hd__tapvpwrvgnd_1
XFILLER_107_402 VGND VGND VPWR VPWR sky130_fd_sc_hd__fill_1
XFILLER_31_57 VGND VGND VPWR VPWR sky130_fd_sc_hd__decap_3
XFILLER_110_6 VGND VGND VPWR VPWR sky130_fd_sc_hd__decap_3
XFILLER_107_479 VGND VGND VPWR VPWR sky130_fd_sc_hd__fill_1
XFILLER_0_212 VGND VGND VPWR VPWR sky130_fd_sc_hd__fill_2
XTAP_TAPCELL_ROW_8_345 VGND VPWR sky130_fd_sc_hd__tapvpwrvgnd_1
XFILLER_0_234 VGND VGND VPWR VPWR sky130_fd_sc_hd__decap_3
XFILLER_0_256 VGND VGND VPWR VPWR sky130_fd_sc_hd__decap_3
XFILLER_103_663 VGND VGND VPWR VPWR sky130_fd_sc_hd__decap_3
XFILLER_0_289 VGND VGND VPWR VPWR sky130_fd_sc_hd__fill_2
XFILLER_29_430 VGND VGND VPWR VPWR sky130_fd_sc_hd__decap_3
XFILLER_48_249 VGND VGND VPWR VPWR sky130_fd_sc_hd__decap_3
XFILLER_56_32 VGND VGND VPWR VPWR sky130_fd_sc_hd__fill_2
XFILLER_76_536 VGND VGND VPWR VPWR sky130_fd_sc_hd__decap_3
XFILLER_76_569 VGND VGND VPWR VPWR sky130_fd_sc_hd__decap_3
XFILLER_88_396 VGND VGND VPWR VPWR sky130_fd_sc_hd__decap_3
XFILLER_29_452 VGND VGND VPWR VPWR sky130_fd_sc_hd__decap_3
XFILLER_56_54 VGND VGND VPWR VPWR sky130_fd_sc_hd__decap_3
XFILLER_91_517 VGND VGND VPWR VPWR sky130_fd_sc_hd__decap_3
XFILLER_44_411 VGND VGND VPWR VPWR sky130_fd_sc_hd__decap_3
XFILLER_56_271 VGND VGND VPWR VPWR sky130_fd_sc_hd__decap_3
XTAP_TAPCELL_ROW_106_1526 VGND VPWR sky130_fd_sc_hd__tapvpwrvgnd_1
XFILLER_44_444 VGND VGND VPWR VPWR sky130_fd_sc_hd__decap_3
XFILLER_44_466 VGND VGND VPWR VPWR sky130_fd_sc_hd__fill_1
XPHY_EDGE_ROW_19_Right_19 VGND VGND VPWR VPWR sky130_fd_sc_hd__decap_3
XFILLER_112_71 VGND VGND VPWR VPWR sky130_fd_sc_hd__decap_3
XFILLER_16_168 VGND VGND VPWR VPWR sky130_fd_sc_hd__decap_3
XFILLER_31_116 VGND VGND VPWR VPWR sky130_fd_sc_hd__decap_3
XFILLER_32_639 VGND VGND VPWR VPWR sky130_fd_sc_hd__decap_3
XFILLER_71_252 VGND VGND VPWR VPWR sky130_fd_sc_hd__decap_3
XFILLER_12_330 VGND VGND VPWR VPWR sky130_fd_sc_hd__decap_3
XFILLER_72_75 VGND VGND VPWR VPWR sky130_fd_sc_hd__decap_3
XFILLER_12_363 VGND VGND VPWR VPWR sky130_fd_sc_hd__fill_1
XFILLER_40_683 VGND VGND VPWR VPWR sky130_fd_sc_hd__decap_3
XFILLER_8_323 VGND VGND VPWR VPWR sky130_fd_sc_hd__decap_3
XFILLER_8_356 VGND VGND VPWR VPWR sky130_fd_sc_hd__decap_3
Xclkbuf_3_1__f_clk clkbuf_0_clk/X VGND VGND VPWR VPWR clkload0/A sky130_fd_sc_hd__clkbuf_16
XFILLER_4_551 VGND VGND VPWR VPWR sky130_fd_sc_hd__decap_3
XPHY_EDGE_ROW_28_Right_28 VGND VGND VPWR VPWR sky130_fd_sc_hd__decap_3
XFILLER_99_628 VGND VGND VPWR VPWR sky130_fd_sc_hd__decap_3
XFILLER_113_416 VGND VGND VPWR VPWR sky130_fd_sc_hd__decap_3
XFILLER_98_138 VGND VGND VPWR VPWR sky130_fd_sc_hd__fill_2
XFILLER_98_105 VGND VGND VPWR VPWR sky130_fd_sc_hd__decap_3
XFILLER_97_83 VGND VGND VPWR VPWR sky130_fd_sc_hd__decap_3
XFILLER_67_525 VGND VGND VPWR VPWR sky130_fd_sc_hd__fill_1
XFILLER_39_249 VGND VGND VPWR VPWR sky130_fd_sc_hd__decap_3
XFILLER_79_396 VGND VGND VPWR VPWR sky130_fd_sc_hd__decap_3
XFILLER_82_539 VGND VGND VPWR VPWR sky130_fd_sc_hd__decap_3
XFILLER_94_388 VGND VGND VPWR VPWR sky130_fd_sc_hd__decap_3
XPHY_EDGE_ROW_37_Right_37 VGND VGND VPWR VPWR sky130_fd_sc_hd__decap_3
XFILLER_62_230 VGND VGND VPWR VPWR sky130_fd_sc_hd__fill_2
X_6840_ _6975_/CLK _6840_/D VGND VGND VPWR VPWR _6840_/Q sky130_fd_sc_hd__dfxtp_2
XFILLER_23_617 VGND VGND VPWR VPWR sky130_fd_sc_hd__decap_3
XFILLER_35_488 VGND VGND VPWR VPWR sky130_fd_sc_hd__fill_2
XFILLER_35_499 VGND VGND VPWR VPWR sky130_fd_sc_hd__decap_3
X_6771_ _6964_/CLK _6771_/D VGND VGND VPWR VPWR _6771_/Q sky130_fd_sc_hd__dfxtp_2
XFILLER_16_680 VGND VGND VPWR VPWR sky130_fd_sc_hd__decap_3
XFILLER_16_691 VGND VGND VPWR VPWR sky130_fd_sc_hd__fill_1
XFILLER_62_285 VGND VGND VPWR VPWR sky130_fd_sc_hd__decap_3
X_3983_ _7349_/Q _7317_/Q _3996_/S VGND VGND VPWR VPWR _7349_/D sky130_fd_sc_hd__mux2_2
XTAP_TAPCELL_ROW_33_645 VGND VPWR sky130_fd_sc_hd__tapvpwrvgnd_1
XFILLER_15_190 VGND VGND VPWR VPWR sky130_fd_sc_hd__decap_3
XTAP_TAPCELL_ROW_61_987 VGND VPWR sky130_fd_sc_hd__tapvpwrvgnd_1
XFILLER_30_182 VGND VGND VPWR VPWR sky130_fd_sc_hd__decap_3
XFILLER_31_683 VGND VGND VPWR VPWR sky130_fd_sc_hd__fill_1
X_5653_ _5664_/B VGND VGND VPWR VPWR _5653_/Y sky130_fd_sc_hd__inv_2
X_4604_ _4667_/B VGND VGND VPWR VPWR _4672_/B sky130_fd_sc_hd__inv_2
XPHY_EDGE_ROW_46_Right_46 VGND VGND VPWR VPWR sky130_fd_sc_hd__decap_3
XFILLER_7_81 VGND VGND VPWR VPWR sky130_fd_sc_hd__decap_3
X_7323_ clkload5/A _7323_/D _6603_/Y VGND VGND VPWR VPWR _7323_/Q sky130_fd_sc_hd__dfrtp_2
XFILLER_104_405 VGND VGND VPWR VPWR sky130_fd_sc_hd__decap_3
XFILLER_116_243 VGND VGND VPWR VPWR sky130_fd_sc_hd__fill_1
XFILLER_104_427 VGND VGND VPWR VPWR sky130_fd_sc_hd__fill_2
XFILLER_116_276 VGND VGND VPWR VPWR sky130_fd_sc_hd__decap_3
XFILLER_116_298 VGND VGND VPWR VPWR sky130_fd_sc_hd__decap_3
X_7254_ clkload8/A _7254_/D _6534_/Y VGND VGND VPWR VPWR _7254_/Q sky130_fd_sc_hd__dfrtp_2
X_4466_ _4466_/A _5650_/A VGND VGND VPWR VPWR _4466_/Y sky130_fd_sc_hd__nand2_2
X_7185_ _7384_/CLK _7185_/D _6465_/Y VGND VGND VPWR VPWR _7185_/Q sky130_fd_sc_hd__dfrtp_2
X_4397_ _4397_/A _4648_/A VGND VGND VPWR VPWR _4647_/C sky130_fd_sc_hd__nor2_2
X_3417_ _3449_/B _3421_/C _3417_/C VGND VGND VPWR VPWR _3417_/X sky130_fd_sc_hd__and3_2
XFILLER_112_460 VGND VGND VPWR VPWR sky130_fd_sc_hd__fill_2
X_3348_ _3369_/A _3353_/A _3330_/A VGND VGND VPWR VPWR _5130_/A sky130_fd_sc_hd__a21oi_2
XTAP_TAPCELL_ROW_5_315 VGND VPWR sky130_fd_sc_hd__tapvpwrvgnd_1
XFILLER_98_672 VGND VGND VPWR VPWR sky130_fd_sc_hd__decap_3
XFILLER_100_622 VGND VGND VPWR VPWR sky130_fd_sc_hd__fill_1
XFILLER_58_536 VGND VGND VPWR VPWR sky130_fd_sc_hd__fill_1
XFILLER_85_333 VGND VGND VPWR VPWR sky130_fd_sc_hd__decap_3
XFILLER_97_193 VGND VGND VPWR VPWR sky130_fd_sc_hd__decap_3
Xhold1001 _7199_/Q VGND VGND VPWR VPWR _5262_/A0 sky130_fd_sc_hd__dlygate4sd3_1
Xhold1012 _7183_/Q VGND VGND VPWR VPWR _5292_/A0 sky130_fd_sc_hd__dlygate4sd3_1
Xhold1023 _7263_/Q VGND VGND VPWR VPWR _4979_/A0 sky130_fd_sc_hd__dlygate4sd3_1
XFILLER_100_666 VGND VGND VPWR VPWR sky130_fd_sc_hd__decap_3
XFILLER_85_355 VGND VGND VPWR VPWR sky130_fd_sc_hd__fill_2
XFILLER_85_366 VGND VGND VPWR VPWR sky130_fd_sc_hd__decap_3
Xhold1034 _7267_/Q VGND VGND VPWR VPWR _4914_/A0 sky130_fd_sc_hd__dlygate4sd3_1
Xhold1045 _7192_/Q VGND VGND VPWR VPWR _5276_/A0 sky130_fd_sc_hd__dlygate4sd3_1
Xhold1056 _7197_/Q VGND VGND VPWR VPWR _5266_/A0 sky130_fd_sc_hd__dlygate4sd3_1
Xhold1067 _7040_/Q VGND VGND VPWR VPWR _5577_/A0 sky130_fd_sc_hd__dlygate4sd3_1
XPHY_EDGE_ROW_55_Right_55 VGND VGND VPWR VPWR sky130_fd_sc_hd__decap_3
XFILLER_38_271 VGND VGND VPWR VPWR sky130_fd_sc_hd__decap_3
XFILLER_73_539 VGND VGND VPWR VPWR sky130_fd_sc_hd__decap_3
XFILLER_85_399 VGND VGND VPWR VPWR sky130_fd_sc_hd__decap_3
Xhold1078 _7299_/Q VGND VGND VPWR VPWR _4563_/A sky130_fd_sc_hd__dlygate4sd3_1
Xhold1089 _7288_/Q VGND VGND VPWR VPWR _4585_/A sky130_fd_sc_hd__dlygate4sd3_1
X_5018_ _5018_/A _5018_/B VGND VGND VPWR VPWR _5018_/Y sky130_fd_sc_hd__nor2_2
XFILLER_26_433 VGND VGND VPWR VPWR sky130_fd_sc_hd__decap_3
XFILLER_26_46 VGND VGND VPWR VPWR sky130_fd_sc_hd__decap_3
XFILLER_14_606 VGND VGND VPWR VPWR sky130_fd_sc_hd__decap_3
XFILLER_26_477 VGND VGND VPWR VPWR sky130_fd_sc_hd__fill_1
XFILLER_53_252 VGND VGND VPWR VPWR sky130_fd_sc_hd__decap_3
XFILLER_81_561 VGND VGND VPWR VPWR sky130_fd_sc_hd__fill_2
XFILLER_41_425 VGND VGND VPWR VPWR sky130_fd_sc_hd__fill_2
XFILLER_41_447 VGND VGND VPWR VPWR sky130_fd_sc_hd__fill_1
X_6969_ _6976_/CLK _6969_/D VGND VGND VPWR VPWR _6969_/Q sky130_fd_sc_hd__dfxtp_2
XTAP_TAPCELL_ROW_101_1467 VGND VPWR sky130_fd_sc_hd__tapvpwrvgnd_1
XPHY_EDGE_ROW_64_Right_64 VGND VGND VPWR VPWR sky130_fd_sc_hd__decap_3
XFILLER_21_193 VGND VGND VPWR VPWR sky130_fd_sc_hd__decap_3
XFILLER_5_326 VGND VGND VPWR VPWR sky130_fd_sc_hd__decap_3
XFILLER_107_287 VGND VGND VPWR VPWR sky130_fd_sc_hd__fill_2
XFILLER_107_298 VGND VGND VPWR VPWR sky130_fd_sc_hd__decap_3
XFILLER_89_650 VGND VGND VPWR VPWR sky130_fd_sc_hd__fill_1
Xhold890 _7094_/Q VGND VGND VPWR VPWR _7094_/D sky130_fd_sc_hd__dlygate4sd3_1
XFILLER_107_60 VGND VGND VPWR VPWR sky130_fd_sc_hd__decap_3
XFILLER_107_93 VGND VGND VPWR VPWR sky130_fd_sc_hd__fill_1
XFILLER_3_39 VGND VGND VPWR VPWR sky130_fd_sc_hd__decap_3
XFILLER_49_503 VGND VGND VPWR VPWR sky130_fd_sc_hd__fill_1
XFILLER_95_108 VGND VGND VPWR VPWR sky130_fd_sc_hd__decap_3
XFILLER_67_42 VGND VGND VPWR VPWR sky130_fd_sc_hd__decap_3
XFILLER_76_333 VGND VGND VPWR VPWR sky130_fd_sc_hd__decap_3
XFILLER_88_171 VGND VGND VPWR VPWR sky130_fd_sc_hd__decap_3
XTAP_TAPCELL_ROW_112_1596 VGND VPWR sky130_fd_sc_hd__tapvpwrvgnd_1
XPHY_EDGE_ROW_73_Right_73 VGND VGND VPWR VPWR sky130_fd_sc_hd__decap_3
XFILLER_17_455 VGND VGND VPWR VPWR sky130_fd_sc_hd__decap_3
XFILLER_29_293 VGND VGND VPWR VPWR sky130_fd_sc_hd__decap_3
XFILLER_44_241 VGND VGND VPWR VPWR sky130_fd_sc_hd__fill_2
XFILLER_91_358 VGND VGND VPWR VPWR sky130_fd_sc_hd__decap_3
XFILLER_72_561 VGND VGND VPWR VPWR sky130_fd_sc_hd__decap_3
XFILLER_83_63 VGND VGND VPWR VPWR sky130_fd_sc_hd__decap_3
XTAP_TAPCELL_ROW_67_1053 VGND VPWR sky130_fd_sc_hd__tapvpwrvgnd_1
XFILLER_44_296 VGND VGND VPWR VPWR sky130_fd_sc_hd__decap_3
XFILLER_72_594 VGND VGND VPWR VPWR sky130_fd_sc_hd__decap_3
XPHY_EDGE_ROW_17_Left_134 VGND VGND VPWR VPWR sky130_fd_sc_hd__decap_3
XPHY_EDGE_ROW_82_Right_82 VGND VGND VPWR VPWR sky130_fd_sc_hd__decap_3
XTAP_TAPCELL_ROW_30_615 VGND VPWR sky130_fd_sc_hd__tapvpwrvgnd_1
XFILLER_12_182 VGND VGND VPWR VPWR sky130_fd_sc_hd__fill_1
XFILLER_73_6 VGND VGND VPWR VPWR sky130_fd_sc_hd__decap_3
XFILLER_8_153 VGND VGND VPWR VPWR sky130_fd_sc_hd__decap_3
XFILLER_9_676 VGND VGND VPWR VPWR sky130_fd_sc_hd__decap_3
XTAP_TAPCELL_ROW_10_372 VGND VPWR sky130_fd_sc_hd__tapvpwrvgnd_1
XFILLER_113_202 VGND VGND VPWR VPWR sky130_fd_sc_hd__decap_3
X_4320_ _7066_/Q _4305_/B _4460_/A VGND VGND VPWR VPWR _4362_/B sky130_fd_sc_hd__o21a_2
XTAP_TAPCELL_ROW_78_1193 VGND VPWR sky130_fd_sc_hd__tapvpwrvgnd_1
XTAP_TAPCELL_ROW_78_1182 VGND VPWR sky130_fd_sc_hd__tapvpwrvgnd_1
XFILLER_99_425 VGND VGND VPWR VPWR sky130_fd_sc_hd__decap_3
XFILLER_113_246 VGND VGND VPWR VPWR sky130_fd_sc_hd__decap_3
X_4251_ _7016_/Q _4356_/A2 _4351_/B1 _7133_/Q _4250_/X VGND VGND VPWR VPWR _4251_/X
+ sky130_fd_sc_hd__a221o_2
XPHY_EDGE_ROW_26_Left_143 VGND VGND VPWR VPWR sky130_fd_sc_hd__decap_3
XFILLER_101_408 VGND VGND VPWR VPWR sky130_fd_sc_hd__decap_3
XFILLER_113_279 VGND VGND VPWR VPWR sky130_fd_sc_hd__fill_1
XPHY_EDGE_ROW_91_Right_91 VGND VGND VPWR VPWR sky130_fd_sc_hd__decap_3
XFILLER_67_333 VGND VGND VPWR VPWR sky130_fd_sc_hd__decap_3
XFILLER_79_193 VGND VGND VPWR VPWR sky130_fd_sc_hd__decap_3
X_4182_ _7136_/Q _4195_/A2 _4180_/X _4181_/X VGND VGND VPWR VPWR _4182_/X sky130_fd_sc_hd__a211o_2
XFILLER_94_141 VGND VGND VPWR VPWR sky130_fd_sc_hd__decap_3
XFILLER_95_653 VGND VGND VPWR VPWR sky130_fd_sc_hd__decap_3
XTAP_TAPCELL_ROW_38_704 VGND VPWR sky130_fd_sc_hd__tapvpwrvgnd_1
XFILLER_103_18 VGND VGND VPWR VPWR sky130_fd_sc_hd__decap_3
XFILLER_55_539 VGND VGND VPWR VPWR sky130_fd_sc_hd__fill_2
XFILLER_67_388 VGND VGND VPWR VPWR sky130_fd_sc_hd__decap_3
XFILLER_82_336 VGND VGND VPWR VPWR sky130_fd_sc_hd__decap_3
XFILLER_50_200 VGND VGND VPWR VPWR sky130_fd_sc_hd__decap_3
XFILLER_63_572 VGND VGND VPWR VPWR sky130_fd_sc_hd__decap_3
XPHY_EDGE_ROW_35_Left_152 VGND VGND VPWR VPWR sky130_fd_sc_hd__decap_3
XFILLER_50_233 VGND VGND VPWR VPWR sky130_fd_sc_hd__decap_3
X_6823_ _6911_/CLK _6823_/D VGND VGND VPWR VPWR _6823_/Q sky130_fd_sc_hd__dfxtp_2
XTAP_TAPCELL_ROW_18_472 VGND VPWR sky130_fd_sc_hd__tapvpwrvgnd_1
X_6754_ _6965_/CLK _6754_/D VGND VGND VPWR VPWR _6754_/Q sky130_fd_sc_hd__dfxtp_2
X_3966_ _7357_/Q _3966_/A1 _3968_/S VGND VGND VPWR VPWR _7357_/D sky130_fd_sc_hd__mux2_2
X_6685_ _6685_/A VGND VGND VPWR VPWR _6685_/Y sky130_fd_sc_hd__inv_2
X_5705_ hold905/X _5719_/S _4270_/Y VGND VGND VPWR VPWR _6702_/D sky130_fd_sc_hd__a21bo_2
XFILLER_109_508 VGND VGND VPWR VPWR sky130_fd_sc_hd__fill_1
XFILLER_12_15 VGND VGND VPWR VPWR sky130_fd_sc_hd__decap_3
X_3897_ hold969/X _3909_/A2 _3896_/Y VGND VGND VPWR VPWR _7382_/D sky130_fd_sc_hd__a21bo_2
XFILLER_12_59 VGND VGND VPWR VPWR sky130_fd_sc_hd__decap_3
X_5567_ hold951/X _4909_/A _4870_/Y VGND VGND VPWR VPWR _7050_/D sky130_fd_sc_hd__a21o_2
XFILLER_2_318 VGND VGND VPWR VPWR sky130_fd_sc_hd__decap_3
X_7306_ _7338_/CLK _7306_/D _6586_/Y VGND VGND VPWR VPWR _7306_/Q sky130_fd_sc_hd__dfrtp_2
XPHY_EDGE_ROW_44_Left_161 VGND VGND VPWR VPWR sky130_fd_sc_hd__decap_3
XFILLER_5_9 VGND VGND VPWR VPWR sky130_fd_sc_hd__decap_3
X_7237_ _7368_/CLK _7237_/D _6517_/Y VGND VGND VPWR VPWR _7237_/Q sky130_fd_sc_hd__dfrtp_2
X_4449_ _4403_/A _4411_/B _4448_/X VGND VGND VPWR VPWR _4761_/C sky130_fd_sc_hd__a21oi_2
XFILLER_58_333 VGND VGND VPWR VPWR sky130_fd_sc_hd__fill_1
X_7168_ _7358_/CLK _7168_/D _6448_/Y VGND VGND VPWR VPWR _7168_/Q sky130_fd_sc_hd__dfrtp_2
XFILLER_98_491 VGND VGND VPWR VPWR sky130_fd_sc_hd__decap_3
XFILLER_100_452 VGND VGND VPWR VPWR sky130_fd_sc_hd__decap_3
XFILLER_37_12 VGND VGND VPWR VPWR sky130_fd_sc_hd__decap_3
XFILLER_58_344 VGND VGND VPWR VPWR sky130_fd_sc_hd__decap_3
XFILLER_85_152 VGND VGND VPWR VPWR sky130_fd_sc_hd__decap_3
X_7099_ clkload8/A _7099_/D _6379_/Y VGND VGND VPWR VPWR _7099_/Q sky130_fd_sc_hd__dfrtp_2
XFILLER_37_45 VGND VGND VPWR VPWR sky130_fd_sc_hd__fill_1
XFILLER_85_174 VGND VGND VPWR VPWR sky130_fd_sc_hd__decap_3
XFILLER_86_686 VGND VGND VPWR VPWR sky130_fd_sc_hd__decap_3
XFILLER_37_78 VGND VGND VPWR VPWR sky130_fd_sc_hd__decap_3
XFILLER_73_347 VGND VGND VPWR VPWR sky130_fd_sc_hd__decap_3
XPHY_EDGE_ROW_53_Left_170 VGND VGND VPWR VPWR sky130_fd_sc_hd__decap_3
XFILLER_54_550 VGND VGND VPWR VPWR sky130_fd_sc_hd__fill_2
XFILLER_26_274 VGND VGND VPWR VPWR sky130_fd_sc_hd__decap_3
XFILLER_53_33 VGND VGND VPWR VPWR sky130_fd_sc_hd__fill_1
XFILLER_54_583 VGND VGND VPWR VPWR sky130_fd_sc_hd__decap_3
XFILLER_81_391 VGND VGND VPWR VPWR sky130_fd_sc_hd__fill_1
XFILLER_41_255 VGND VGND VPWR VPWR sky130_fd_sc_hd__decap_3
XFILLER_53_66 VGND VGND VPWR VPWR sky130_fd_sc_hd__decap_3
XFILLER_22_480 VGND VGND VPWR VPWR sky130_fd_sc_hd__fill_2
XFILLER_41_299 VGND VGND VPWR VPWR sky130_fd_sc_hd__decap_3
XFILLER_108_530 VGND VGND VPWR VPWR sky130_fd_sc_hd__fill_2
XFILLER_5_145 VGND VGND VPWR VPWR sky130_fd_sc_hd__decap_3
XFILLER_6_657 VGND VGND VPWR VPWR sky130_fd_sc_hd__decap_3
XFILLER_5_178 VGND VGND VPWR VPWR sky130_fd_sc_hd__decap_3
XTAP_TAPCELL_ROW_114_1625 VGND VPWR sky130_fd_sc_hd__tapvpwrvgnd_1
XTAP_TAPCELL_ROW_114_1614 VGND VPWR sky130_fd_sc_hd__tapvpwrvgnd_1
XFILLER_69_609 VGND VGND VPWR VPWR sky130_fd_sc_hd__decap_3
XFILLER_78_41 VGND VGND VPWR VPWR sky130_fd_sc_hd__decap_3
XFILLER_38_9 VGND VGND VPWR VPWR sky130_fd_sc_hd__decap_3
XFILLER_78_85 VGND VGND VPWR VPWR sky130_fd_sc_hd__decap_3
XFILLER_96_406 VGND VGND VPWR VPWR sky130_fd_sc_hd__decap_3
XFILLER_110_238 VGND VGND VPWR VPWR sky130_fd_sc_hd__fill_1
XFILLER_1_384 VGND VGND VPWR VPWR sky130_fd_sc_hd__decap_3
XFILLER_103_290 VGND VGND VPWR VPWR sky130_fd_sc_hd__decap_3
XFILLER_64_303 VGND VGND VPWR VPWR sky130_fd_sc_hd__decap_3
XFILLER_91_100 VGND VGND VPWR VPWR sky130_fd_sc_hd__fill_2
XFILLER_91_111 VGND VGND VPWR VPWR sky130_fd_sc_hd__fill_1
XFILLER_92_634 VGND VGND VPWR VPWR sky130_fd_sc_hd__decap_3
XFILLER_94_73 VGND VGND VPWR VPWR sky130_fd_sc_hd__decap_3
XFILLER_17_252 VGND VGND VPWR VPWR sky130_fd_sc_hd__decap_3
XFILLER_45_561 VGND VGND VPWR VPWR sky130_fd_sc_hd__fill_2
XFILLER_91_155 VGND VGND VPWR VPWR sky130_fd_sc_hd__decap_3
XFILLER_92_678 VGND VGND VPWR VPWR sky130_fd_sc_hd__decap_3
XFILLER_32_200 VGND VGND VPWR VPWR sky130_fd_sc_hd__decap_3
XFILLER_60_531 VGND VGND VPWR VPWR sky130_fd_sc_hd__fill_1
XFILLER_72_391 VGND VGND VPWR VPWR sky130_fd_sc_hd__decap_3
XFILLER_32_244 VGND VGND VPWR VPWR sky130_fd_sc_hd__decap_3
X_3820_ _6927_/Q _3926_/A2 _3925_/A2 _6701_/Q VGND VGND VPWR VPWR _3820_/X sky130_fd_sc_hd__a22o_2
XTAP_TAPCELL_ROW_43_762 VGND VPWR sky130_fd_sc_hd__tapvpwrvgnd_1
XTAP_TAPCELL_ROW_15_431 VGND VPWR sky130_fd_sc_hd__tapvpwrvgnd_1
XFILLER_32_277 VGND VGND VPWR VPWR sky130_fd_sc_hd__decap_3
X_3751_ _6935_/Q _3926_/A2 _3925_/B1 _6887_/Q VGND VGND VPWR VPWR _3751_/X sky130_fd_sc_hd__a22o_2
XTAP_TAPCELL_ROW_43_773 VGND VPWR sky130_fd_sc_hd__tapvpwrvgnd_1
XFILLER_71_3 VGND VGND VPWR VPWR sky130_fd_sc_hd__decap_3
X_6470_ _6562_/A VGND VGND VPWR VPWR _6470_/Y sky130_fd_sc_hd__inv_2
X_3682_ _3682_/A _3682_/B VGND VGND VPWR VPWR _3682_/Y sky130_fd_sc_hd__nand2_2
X_5421_ _7123_/Q _5135_/X _5429_/S VGND VGND VPWR VPWR _7123_/D sky130_fd_sc_hd__mux2_2
X_5352_ _5352_/A0 _5135_/X _5360_/S VGND VGND VPWR VPWR _7155_/D sky130_fd_sc_hd__mux2_2
X_4303_ _7320_/Q _3977_/S wire566/X _7128_/Q _4302_/X VGND VGND VPWR VPWR _4303_/X
+ sky130_fd_sc_hd__a221o_2
XFILLER_99_233 VGND VGND VPWR VPWR sky130_fd_sc_hd__decap_3
XFILLER_114_566 VGND VGND VPWR VPWR sky130_fd_sc_hd__decap_3
X_7022_ _7369_/CLK _7022_/D _6302_/Y VGND VGND VPWR VPWR _7022_/Q sky130_fd_sc_hd__dfrtp_2
X_5283_ _3600_/A _4788_/A _5238_/X hold958/X VGND VGND VPWR VPWR _7188_/D sky130_fd_sc_hd__a22o_2
XFILLER_4_71 VGND VGND VPWR VPWR sky130_fd_sc_hd__decap_3
XFILLER_68_631 VGND VGND VPWR VPWR sky130_fd_sc_hd__decap_3
XFILLER_87_439 VGND VGND VPWR VPWR sky130_fd_sc_hd__decap_3
X_4234_ _7355_/Q _4338_/B1 _4233_/X _3556_/A VGND VGND VPWR VPWR _4234_/X sky130_fd_sc_hd__a211o_2
XFILLER_99_299 VGND VGND VPWR VPWR sky130_fd_sc_hd__decap_3
X_4165_ _7018_/Q _4422_/A2 _4195_/A2 _7137_/Q _4164_/X VGND VGND VPWR VPWR _4165_/X
+ sky130_fd_sc_hd__a221o_2
XFILLER_82_100 VGND VGND VPWR VPWR sky130_fd_sc_hd__decap_3
XFILLER_95_494 VGND VGND VPWR VPWR sky130_fd_sc_hd__fill_2
XFILLER_82_133 VGND VGND VPWR VPWR sky130_fd_sc_hd__decap_3
XFILLER_83_656 VGND VGND VPWR VPWR sky130_fd_sc_hd__decap_3
X_4096_ _4096_/A _4096_/B VGND VGND VPWR VPWR _4633_/A sky130_fd_sc_hd__nand2_2
XFILLER_82_177 VGND VGND VPWR VPWR sky130_fd_sc_hd__decap_3
XFILLER_23_222 VGND VGND VPWR VPWR sky130_fd_sc_hd__fill_2
XFILLER_63_391 VGND VGND VPWR VPWR sky130_fd_sc_hd__fill_1
Xplace380 wire566/X VGND VGND VPWR VPWR _4348_/B1 sky130_fd_sc_hd__buf_2
Xplace391 _5642_/A VGND VGND VPWR VPWR _5666_/A sky130_fd_sc_hd__buf_2
X_6806_ _6959_/CLK _6806_/D VGND VGND VPWR VPWR _6806_/Q sky130_fd_sc_hd__dfxtp_2
XFILLER_11_417 VGND VGND VPWR VPWR sky130_fd_sc_hd__decap_3
XFILLER_23_277 VGND VGND VPWR VPWR sky130_fd_sc_hd__decap_3
X_4998_ _4998_/A0 _4997_/X _5028_/S VGND VGND VPWR VPWR _7262_/D sky130_fd_sc_hd__mux2_2
XFILLER_23_69 VGND VGND VPWR VPWR sky130_fd_sc_hd__decap_3
X_6737_ _6931_/CLK _6737_/D VGND VGND VPWR VPWR _6737_/Q sky130_fd_sc_hd__dfxtp_2
X_3949_ _7365_/Q _4493_/A0 _3949_/S VGND VGND VPWR VPWR _7365_/D sky130_fd_sc_hd__mux2_2
X_6668_ _6670_/A VGND VGND VPWR VPWR _6668_/Y sky130_fd_sc_hd__inv_2
XFILLER_99_18 VGND VGND VPWR VPWR sky130_fd_sc_hd__fill_1
X_6599_ _6599_/A VGND VGND VPWR VPWR _6599_/Y sky130_fd_sc_hd__inv_2
X_5619_ _5619_/A _5633_/B VGND VGND VPWR VPWR _7018_/D sky130_fd_sc_hd__or2_2
XFILLER_105_500 VGND VGND VPWR VPWR sky130_fd_sc_hd__decap_3
XFILLER_105_511 VGND VGND VPWR VPWR sky130_fd_sc_hd__decap_3
XFILLER_2_115 VGND VGND VPWR VPWR sky130_fd_sc_hd__decap_3
XFILLER_3_6 VGND VGND VPWR VPWR sky130_fd_sc_hd__decap_3
XFILLER_3_638 VGND VGND VPWR VPWR sky130_fd_sc_hd__decap_3
XFILLER_105_555 VGND VGND VPWR VPWR sky130_fd_sc_hd__decap_3
XFILLER_105_588 VGND VGND VPWR VPWR sky130_fd_sc_hd__fill_1
XFILLER_78_406 VGND VGND VPWR VPWR sky130_fd_sc_hd__decap_3
XFILLER_48_22 VGND VGND VPWR VPWR sky130_fd_sc_hd__decap_3
XFILLER_59_620 VGND VGND VPWR VPWR sky130_fd_sc_hd__decap_3
XFILLER_48_44 VGND VGND VPWR VPWR sky130_fd_sc_hd__decap_3
XFILLER_48_55 VGND VGND VPWR VPWR sky130_fd_sc_hd__decap_3
XFILLER_58_141 VGND VGND VPWR VPWR sky130_fd_sc_hd__decap_3
XFILLER_59_653 VGND VGND VPWR VPWR sky130_fd_sc_hd__decap_3
XFILLER_58_174 VGND VGND VPWR VPWR sky130_fd_sc_hd__fill_2
XFILLER_74_601 VGND VGND VPWR VPWR sky130_fd_sc_hd__decap_3
XFILLER_74_623 VGND VGND VPWR VPWR sky130_fd_sc_hd__fill_2
XFILLER_0_29 VGND VGND VPWR VPWR sky130_fd_sc_hd__decap_3
XFILLER_100_293 VGND VGND VPWR VPWR sky130_fd_sc_hd__decap_3
XFILLER_104_50 VGND VGND VPWR VPWR sky130_fd_sc_hd__fill_1
XFILLER_104_72 VGND VGND VPWR VPWR sky130_fd_sc_hd__decap_3
XFILLER_46_347 VGND VGND VPWR VPWR sky130_fd_sc_hd__decap_3
XFILLER_64_21 VGND VGND VPWR VPWR sky130_fd_sc_hd__decap_3
XFILLER_74_645 VGND VGND VPWR VPWR sky130_fd_sc_hd__decap_3
XFILLER_27_561 VGND VGND VPWR VPWR sky130_fd_sc_hd__decap_3
XFILLER_61_317 VGND VGND VPWR VPWR sky130_fd_sc_hd__decap_3
XFILLER_64_32 VGND VGND VPWR VPWR sky130_fd_sc_hd__decap_3
XFILLER_73_155 VGND VGND VPWR VPWR sky130_fd_sc_hd__fill_1
XFILLER_74_678 VGND VGND VPWR VPWR sky130_fd_sc_hd__decap_3
XFILLER_14_200 VGND VGND VPWR VPWR sky130_fd_sc_hd__decap_3
XFILLER_64_65 VGND VGND VPWR VPWR sky130_fd_sc_hd__decap_3
XTAP_TAPCELL_ROW_64_1023 VGND VPWR sky130_fd_sc_hd__tapvpwrvgnd_1
XFILLER_14_233 VGND VGND VPWR VPWR sky130_fd_sc_hd__decap_3
XFILLER_9_27 VGND VGND VPWR VPWR sky130_fd_sc_hd__decap_3
XFILLER_80_20 VGND VGND VPWR VPWR sky130_fd_sc_hd__decap_3
XTAP_TAPCELL_ROW_12_401 VGND VPWR sky130_fd_sc_hd__tapvpwrvgnd_1
XFILLER_14_299 VGND VGND VPWR VPWR sky130_fd_sc_hd__fill_1
XFILLER_80_53 VGND VGND VPWR VPWR sky130_fd_sc_hd__decap_3
Xfanout70 _6523_/A VGND VGND VPWR VPWR _6525_/A sky130_fd_sc_hd__buf_1
XTAP_TAPCELL_ROW_40_732 VGND VPWR sky130_fd_sc_hd__tapvpwrvgnd_1
XFILLER_10_472 VGND VGND VPWR VPWR sky130_fd_sc_hd__decap_3
XFILLER_115_308 VGND VGND VPWR VPWR sky130_fd_sc_hd__decap_3
XFILLER_89_51 VGND VGND VPWR VPWR sky130_fd_sc_hd__decap_3
XPHY_EDGE_ROW_108_Right_108 VGND VGND VPWR VPWR sky130_fd_sc_hd__decap_3
XTAP_TAPCELL_ROW_75_1152 VGND VPWR sky130_fd_sc_hd__tapvpwrvgnd_1
XFILLER_2_660 VGND VGND VPWR VPWR sky130_fd_sc_hd__decap_3
XFILLER_69_406 VGND VGND VPWR VPWR sky130_fd_sc_hd__decap_3
XFILLER_111_514 VGND VGND VPWR VPWR sky130_fd_sc_hd__decap_3
XFILLER_36_6 VGND VGND VPWR VPWR sky130_fd_sc_hd__decap_3
XFILLER_49_141 VGND VGND VPWR VPWR sky130_fd_sc_hd__decap_3
XFILLER_96_269 VGND VGND VPWR VPWR sky130_fd_sc_hd__fill_1
XFILLER_49_174 VGND VGND VPWR VPWR sky130_fd_sc_hd__decap_3
XFILLER_65_623 VGND VGND VPWR VPWR sky130_fd_sc_hd__decap_3
XFILLER_77_461 VGND VGND VPWR VPWR sky130_fd_sc_hd__decap_3
XFILLER_37_325 VGND VGND VPWR VPWR sky130_fd_sc_hd__decap_3
XFILLER_65_656 VGND VGND VPWR VPWR sky130_fd_sc_hd__decap_3
XTAP_TAPCELL_ROW_48_832 VGND VPWR sky130_fd_sc_hd__tapvpwrvgnd_1
XFILLER_92_475 VGND VGND VPWR VPWR sky130_fd_sc_hd__fill_1
XFILLER_92_486 VGND VGND VPWR VPWR sky130_fd_sc_hd__decap_3
XFILLER_52_339 VGND VGND VPWR VPWR sky130_fd_sc_hd__decap_3
X_4921_ _4968_/A _4383_/C _4201_/X VGND VGND VPWR VPWR _4937_/B sky130_fd_sc_hd__a21bo_2
XTAP_TAPCELL_ROW_86_1281 VGND VPWR sky130_fd_sc_hd__tapvpwrvgnd_1
X_4852_ _4852_/A _5057_/A VGND VGND VPWR VPWR _5101_/A sky130_fd_sc_hd__and2_2
XFILLER_20_203 VGND VGND VPWR VPWR sky130_fd_sc_hd__decap_3
XFILLER_60_383 VGND VGND VPWR VPWR sky130_fd_sc_hd__decap_3
X_3803_ _6816_/Q _3889_/A2 _3878_/B1 _6821_/Q VGND VGND VPWR VPWR _3803_/X sky130_fd_sc_hd__a22o_2
X_4783_ _4646_/A _4646_/B _4827_/A VGND VGND VPWR VPWR _4829_/B sky130_fd_sc_hd__a21boi_2
XFILLER_20_269 VGND VGND VPWR VPWR sky130_fd_sc_hd__decap_3
X_6522_ _6522_/A VGND VGND VPWR VPWR _6522_/Y sky130_fd_sc_hd__inv_2
X_3734_ _3728_/Y _3730_/X _3732_/X _3733_/X VGND VGND VPWR VPWR _3734_/X sky130_fd_sc_hd__a22o_2
X_6453_ _6642_/A VGND VGND VPWR VPWR _6453_/Y sky130_fd_sc_hd__inv_2
X_3665_ _3665_/A _3665_/B VGND VGND VPWR VPWR _3665_/X sky130_fd_sc_hd__and2_4
XFILLER_109_39 VGND VGND VPWR VPWR sky130_fd_sc_hd__decap_3
X_5404_ _5404_/A0 _5040_/X _5417_/S VGND VGND VPWR VPWR _7131_/D sky130_fd_sc_hd__mux2_2
X_6384_ _6604_/A VGND VGND VPWR VPWR _6384_/Y sky130_fd_sc_hd__inv_2
X_3596_ _4295_/B _3607_/B VGND VGND VPWR VPWR _3598_/A sky130_fd_sc_hd__and2_2
XFILLER_102_525 VGND VGND VPWR VPWR sky130_fd_sc_hd__decap_3
X_5266_ _5266_/A0 _5011_/X _5274_/S VGND VGND VPWR VPWR _7197_/D sky130_fd_sc_hd__mux2_2
XFILLER_87_258 VGND VGND VPWR VPWR sky130_fd_sc_hd__decap_3
X_7005_ _7005_/CLK _7005_/D _6285_/Y VGND VGND VPWR VPWR _7005_/Q sky130_fd_sc_hd__dfrtp_2
X_4217_ _3469_/A _3469_/B _3449_/A _7015_/Q _3365_/A VGND VGND VPWR VPWR _4217_/X
+ sky130_fd_sc_hd__o2111a_2
XFILLER_28_303 VGND VGND VPWR VPWR sky130_fd_sc_hd__decap_3
XFILLER_56_612 VGND VGND VPWR VPWR sky130_fd_sc_hd__decap_3
XFILLER_68_461 VGND VGND VPWR VPWR sky130_fd_sc_hd__decap_3
XFILLER_68_483 VGND VGND VPWR VPWR sky130_fd_sc_hd__decap_3
XFILLER_110_580 VGND VGND VPWR VPWR sky130_fd_sc_hd__decap_3
XFILLER_18_47 VGND VGND VPWR VPWR sky130_fd_sc_hd__decap_3
XFILLER_55_111 VGND VGND VPWR VPWR sky130_fd_sc_hd__fill_1
XFILLER_56_645 VGND VGND VPWR VPWR sky130_fd_sc_hd__decap_3
XFILLER_83_442 VGND VGND VPWR VPWR sky130_fd_sc_hd__decap_3
X_4148_ _7074_/Q _4265_/B _4145_/X _4147_/X VGND VGND VPWR VPWR _4205_/B sky130_fd_sc_hd__o22a_2
XFILLER_28_358 VGND VGND VPWR VPWR sky130_fd_sc_hd__decap_3
XFILLER_28_369 VGND VGND VPWR VPWR sky130_fd_sc_hd__decap_3
XFILLER_55_155 VGND VGND VPWR VPWR sky130_fd_sc_hd__decap_3
XFILLER_56_678 VGND VGND VPWR VPWR sky130_fd_sc_hd__decap_3
XFILLER_71_615 VGND VGND VPWR VPWR sky130_fd_sc_hd__fill_1
XFILLER_71_626 VGND VGND VPWR VPWR sky130_fd_sc_hd__decap_3
X_4079_ _7403_/Q _4437_/B1 _4077_/X _4078_/X VGND VGND VPWR VPWR _4079_/X sky130_fd_sc_hd__a211o_2
XFILLER_70_125 VGND VGND VPWR VPWR sky130_fd_sc_hd__decap_3
XFILLER_71_659 VGND VGND VPWR VPWR sky130_fd_sc_hd__decap_3
XFILLER_24_531 VGND VGND VPWR VPWR sky130_fd_sc_hd__fill_1
XFILLER_24_564 VGND VGND VPWR VPWR sky130_fd_sc_hd__decap_3
XFILLER_34_35 VGND VGND VPWR VPWR sky130_fd_sc_hd__fill_2
XFILLER_70_147 VGND VGND VPWR VPWR sky130_fd_sc_hd__decap_3
XFILLER_70_158 VGND VGND VPWR VPWR sky130_fd_sc_hd__decap_3
XTAP_TAPCELL_ROW_26_559 VGND VPWR sky130_fd_sc_hd__tapvpwrvgnd_1
XFILLER_11_214 VGND VGND VPWR VPWR sky130_fd_sc_hd__decap_3
XFILLER_24_597 VGND VGND VPWR VPWR sky130_fd_sc_hd__decap_3
XFILLER_11_225 VGND VGND VPWR VPWR sky130_fd_sc_hd__decap_3
XFILLER_109_113 VGND VGND VPWR VPWR sky130_fd_sc_hd__decap_3
XFILLER_11_269 VGND VGND VPWR VPWR sky130_fd_sc_hd__decap_3
XFILLER_7_218 VGND VGND VPWR VPWR sky130_fd_sc_hd__decap_3
Xclkload1 clkload1/A VGND VGND VPWR VPWR clkload1/X sky130_fd_sc_hd__clkbuf_16
XFILLER_50_56 VGND VGND VPWR VPWR sky130_fd_sc_hd__decap_3
XFILLER_3_402 VGND VGND VPWR VPWR sky130_fd_sc_hd__decap_3
XFILLER_3_435 VGND VGND VPWR VPWR sky130_fd_sc_hd__decap_3
XFILLER_59_54 VGND VGND VPWR VPWR sky130_fd_sc_hd__fill_2
XFILLER_78_203 VGND VGND VPWR VPWR sky130_fd_sc_hd__decap_3
XFILLER_59_87 VGND VGND VPWR VPWR sky130_fd_sc_hd__decap_3
XFILLER_78_269 VGND VGND VPWR VPWR sky130_fd_sc_hd__decap_3
XFILLER_115_60 VGND VGND VPWR VPWR sky130_fd_sc_hd__decap_3
XFILLER_47_623 VGND VGND VPWR VPWR sky130_fd_sc_hd__decap_3
XFILLER_93_228 VGND VGND VPWR VPWR sky130_fd_sc_hd__decap_3
XFILLER_101_580 VGND VGND VPWR VPWR sky130_fd_sc_hd__decap_3
XFILLER_115_93 VGND VGND VPWR VPWR sky130_fd_sc_hd__decap_3
XFILLER_46_122 VGND VGND VPWR VPWR sky130_fd_sc_hd__decap_3
XFILLER_47_656 VGND VGND VPWR VPWR sky130_fd_sc_hd__decap_3
XFILLER_75_31 VGND VGND VPWR VPWR sky130_fd_sc_hd__fill_2
XTAP_TAPCELL_ROW_70_1093 VGND VPWR sky130_fd_sc_hd__tapvpwrvgnd_1
XFILLER_46_144 VGND VGND VPWR VPWR sky130_fd_sc_hd__fill_2
XFILLER_75_75 VGND VGND VPWR VPWR sky130_fd_sc_hd__decap_3
XTAP_TAPCELL_ROW_109_1557 VGND VPWR sky130_fd_sc_hd__tapvpwrvgnd_1
XFILLER_46_177 VGND VGND VPWR VPWR sky130_fd_sc_hd__decap_3
XFILLER_61_103 VGND VGND VPWR VPWR sky130_fd_sc_hd__decap_3
XFILLER_62_626 VGND VGND VPWR VPWR sky130_fd_sc_hd__decap_3
XFILLER_62_648 VGND VGND VPWR VPWR sky130_fd_sc_hd__decap_3
XFILLER_74_486 VGND VGND VPWR VPWR sky130_fd_sc_hd__decap_3
XFILLER_61_169 VGND VGND VPWR VPWR sky130_fd_sc_hd__decap_3
XFILLER_91_41 VGND VGND VPWR VPWR sky130_fd_sc_hd__fill_1
XFILLER_15_564 VGND VGND VPWR VPWR sky130_fd_sc_hd__decap_3
XFILLER_30_512 VGND VGND VPWR VPWR sky130_fd_sc_hd__fill_2
XFILLER_42_350 VGND VGND VPWR VPWR sky130_fd_sc_hd__decap_3
XFILLER_91_74 VGND VGND VPWR VPWR sky130_fd_sc_hd__decap_3
XTAP_TAPCELL_ROW_53_890 VGND VPWR sky130_fd_sc_hd__tapvpwrvgnd_1
XFILLER_115_105 VGND VGND VPWR VPWR sky130_fd_sc_hd__decap_3
XFILLER_116_606 VGND VGND VPWR VPWR sky130_fd_sc_hd__decap_3
XFILLER_116_617 VGND VGND VPWR VPWR sky130_fd_sc_hd__decap_3
Xhold708 _6836_/Q VGND VGND VPWR VPWR _6836_/D sky130_fd_sc_hd__dlygate4sd3_1
Xhold719 _6920_/Q VGND VGND VPWR VPWR _6920_/D sky130_fd_sc_hd__dlygate4sd3_1
XFILLER_109_691 VGND VGND VPWR VPWR sky130_fd_sc_hd__fill_1
XFILLER_115_116 VGND VGND VPWR VPWR sky130_fd_sc_hd__decap_3
XFILLER_115_149 VGND VGND VPWR VPWR sky130_fd_sc_hd__decap_3
XFILLER_6_295 VGND VGND VPWR VPWR sky130_fd_sc_hd__decap_3
XFILLER_69_225 VGND VGND VPWR VPWR sky130_fd_sc_hd__decap_3
XFILLER_97_523 VGND VGND VPWR VPWR sky130_fd_sc_hd__decap_3
X_5120_ _5120_/A _5120_/B VGND VGND VPWR VPWR _6984_/D sky130_fd_sc_hd__nor2_2
XFILLER_111_333 VGND VGND VPWR VPWR sky130_fd_sc_hd__decap_3
XFILLER_111_355 VGND VGND VPWR VPWR sky130_fd_sc_hd__decap_3
XFILLER_69_269 VGND VGND VPWR VPWR sky130_fd_sc_hd__decap_3
XFILLER_97_556 VGND VGND VPWR VPWR sky130_fd_sc_hd__decap_3
X_5051_ _5073_/A _5050_/X _5054_/A VGND VGND VPWR VPWR _5051_/X sky130_fd_sc_hd__a21o_2
XFILLER_38_612 VGND VGND VPWR VPWR sky130_fd_sc_hd__decap_3
XFILLER_1_50 VGND VGND VPWR VPWR sky130_fd_sc_hd__decap_3
XFILLER_77_291 VGND VGND VPWR VPWR sky130_fd_sc_hd__decap_3
XFILLER_84_239 VGND VGND VPWR VPWR sky130_fd_sc_hd__fill_2
XTAP_TAPCELL_ROW_88_1310 VGND VPWR sky130_fd_sc_hd__tapvpwrvgnd_1
XFILLER_1_72 VGND VGND VPWR VPWR sky130_fd_sc_hd__decap_3
XFILLER_37_155 VGND VGND VPWR VPWR sky130_fd_sc_hd__decap_3
XFILLER_53_604 VGND VGND VPWR VPWR sky130_fd_sc_hd__decap_3
XFILLER_65_475 VGND VGND VPWR VPWR sky130_fd_sc_hd__decap_3
XFILLER_80_401 VGND VGND VPWR VPWR sky130_fd_sc_hd__decap_3
XFILLER_37_199 VGND VGND VPWR VPWR sky130_fd_sc_hd__decap_3
XFILLER_53_626 VGND VGND VPWR VPWR sky130_fd_sc_hd__decap_3
XFILLER_92_294 VGND VGND VPWR VPWR sky130_fd_sc_hd__decap_3
XPHY_EDGE_ROW_9_Left_126 VGND VGND VPWR VPWR sky130_fd_sc_hd__decap_3
XFILLER_52_147 VGND VGND VPWR VPWR sky130_fd_sc_hd__decap_3
XFILLER_21_501 VGND VGND VPWR VPWR sky130_fd_sc_hd__decap_3
XFILLER_40_309 VGND VGND VPWR VPWR sky130_fd_sc_hd__decap_3
XFILLER_80_489 VGND VGND VPWR VPWR sky130_fd_sc_hd__decap_3
X_4904_ _4903_/A _4904_/B VGND VGND VPWR VPWR _4904_/X sky130_fd_sc_hd__and2b_2
XTAP_TAPCELL_ROW_23_529 VGND VPWR sky130_fd_sc_hd__tapvpwrvgnd_1
X_4835_ _4467_/B _3709_/X _4832_/X _4834_/Y VGND VGND VPWR VPWR _4835_/X sky130_fd_sc_hd__a31o_2
XFILLER_21_578 VGND VGND VPWR VPWR sky130_fd_sc_hd__fill_2
X_4766_ _4766_/A VGND VGND VPWR VPWR _4766_/Y sky130_fd_sc_hd__inv_2
X_6505_ _6535_/A VGND VGND VPWR VPWR _6505_/Y sky130_fd_sc_hd__inv_2
XFILLER_20_15 VGND VGND VPWR VPWR sky130_fd_sc_hd__decap_3
X_4697_ _6983_/Q _6984_/Q _5670_/B VGND VGND VPWR VPWR _5120_/A sky130_fd_sc_hd__and3_2
XFILLER_105_9 VGND VGND VPWR VPWR sky130_fd_sc_hd__decap_3
X_6436_ _6570_/A VGND VGND VPWR VPWR _6436_/Y sky130_fd_sc_hd__inv_2
XFILLER_115_650 VGND VGND VPWR VPWR sky130_fd_sc_hd__decap_3
X_6367_ _6567_/A VGND VGND VPWR VPWR _6367_/Y sky130_fd_sc_hd__inv_2
X_3579_ _7220_/Q _4230_/A2 _3977_/S _7188_/Q VGND VGND VPWR VPWR _3579_/X sky130_fd_sc_hd__a22o_2
XFILLER_0_405 VGND VGND VPWR VPWR sky130_fd_sc_hd__fill_1
XFILLER_0_427 VGND VGND VPWR VPWR sky130_fd_sc_hd__decap_3
XFILLER_102_300 VGND VGND VPWR VPWR sky130_fd_sc_hd__decap_3
XFILLER_114_171 VGND VGND VPWR VPWR sky130_fd_sc_hd__decap_3
XFILLER_0_449 VGND VGND VPWR VPWR sky130_fd_sc_hd__decap_3
XFILLER_29_24 VGND VGND VPWR VPWR sky130_fd_sc_hd__decap_3
XFILLER_88_567 VGND VGND VPWR VPWR sky130_fd_sc_hd__fill_1
X_6298_ _6611_/A VGND VGND VPWR VPWR _6298_/Y sky130_fd_sc_hd__inv_2
XFILLER_102_377 VGND VGND VPWR VPWR sky130_fd_sc_hd__decap_3
XFILLER_29_57 VGND VGND VPWR VPWR sky130_fd_sc_hd__decap_3
XFILLER_29_601 VGND VGND VPWR VPWR sky130_fd_sc_hd__decap_3
XFILLER_75_206 VGND VGND VPWR VPWR sky130_fd_sc_hd__decap_3
XFILLER_88_589 VGND VGND VPWR VPWR sky130_fd_sc_hd__decap_3
X_5249_ _5249_/A0 _4878_/X _5262_/S VGND VGND VPWR VPWR _7205_/D sky130_fd_sc_hd__mux2_2
XFILLER_28_100 VGND VGND VPWR VPWR sky130_fd_sc_hd__decap_3
XFILLER_29_645 VGND VGND VPWR VPWR sky130_fd_sc_hd__fill_2
XFILLER_28_144 VGND VGND VPWR VPWR sky130_fd_sc_hd__decap_3
XFILLER_56_475 VGND VGND VPWR VPWR sky130_fd_sc_hd__fill_1
XFILLER_83_250 VGND VGND VPWR VPWR sky130_fd_sc_hd__decap_3
XTAP_TAPCELL_ROW_3_287 VGND VPWR sky130_fd_sc_hd__tapvpwrvgnd_1
XFILLER_28_177 VGND VGND VPWR VPWR sky130_fd_sc_hd__decap_3
XFILLER_44_648 VGND VGND VPWR VPWR sky130_fd_sc_hd__decap_3
XFILLER_45_45 VGND VGND VPWR VPWR sky130_fd_sc_hd__decap_3
XFILLER_45_78 VGND VGND VPWR VPWR sky130_fd_sc_hd__decap_3
XFILLER_71_445 VGND VGND VPWR VPWR sky130_fd_sc_hd__decap_3
XFILLER_101_51 VGND VGND VPWR VPWR sky130_fd_sc_hd__decap_3
XFILLER_43_169 VGND VGND VPWR VPWR sky130_fd_sc_hd__decap_3
XFILLER_52_681 VGND VGND VPWR VPWR sky130_fd_sc_hd__decap_3
XFILLER_71_478 VGND VGND VPWR VPWR sky130_fd_sc_hd__decap_3
XFILLER_12_523 VGND VGND VPWR VPWR sky130_fd_sc_hd__fill_1
XFILLER_61_22 VGND VGND VPWR VPWR sky130_fd_sc_hd__decap_3
XTAP_TAPCELL_ROW_104_1498 VGND VPWR sky130_fd_sc_hd__tapvpwrvgnd_1
XFILLER_101_95 VGND VGND VPWR VPWR sky130_fd_sc_hd__decap_3
XFILLER_12_567 VGND VGND VPWR VPWR sky130_fd_sc_hd__decap_3
XFILLER_61_55 VGND VGND VPWR VPWR sky130_fd_sc_hd__fill_1
XFILLER_61_66 VGND VGND VPWR VPWR sky130_fd_sc_hd__decap_3
XFILLER_113_609 VGND VGND VPWR VPWR sky130_fd_sc_hd__decap_3
XFILLER_106_672 VGND VGND VPWR VPWR sky130_fd_sc_hd__decap_3
XFILLER_3_276 VGND VGND VPWR VPWR sky130_fd_sc_hd__decap_3
XFILLER_79_534 VGND VGND VPWR VPWR sky130_fd_sc_hd__decap_3
XTAP_TAPCELL_ROW_72_1111 VGND VPWR sky130_fd_sc_hd__tapvpwrvgnd_1
XFILLER_105_182 VGND VGND VPWR VPWR sky130_fd_sc_hd__fill_1
XFILLER_79_556 VGND VGND VPWR VPWR sky130_fd_sc_hd__decap_3
XFILLER_20_9 VGND VGND VPWR VPWR sky130_fd_sc_hd__decap_3
XFILLER_39_409 VGND VGND VPWR VPWR sky130_fd_sc_hd__decap_3
XFILLER_79_578 VGND VGND VPWR VPWR sky130_fd_sc_hd__decap_3
XFILLER_86_52 VGND VGND VPWR VPWR sky130_fd_sc_hd__decap_3
XFILLER_19_111 VGND VGND VPWR VPWR sky130_fd_sc_hd__fill_1
XFILLER_86_85 VGND VGND VPWR VPWR sky130_fd_sc_hd__decap_3
XFILLER_19_144 VGND VGND VPWR VPWR sky130_fd_sc_hd__decap_3
XFILLER_74_250 VGND VGND VPWR VPWR sky130_fd_sc_hd__fill_2
XFILLER_19_199 VGND VGND VPWR VPWR sky130_fd_sc_hd__decap_3
XFILLER_34_103 VGND VGND VPWR VPWR sky130_fd_sc_hd__decap_3
XFILLER_35_648 VGND VGND VPWR VPWR sky130_fd_sc_hd__fill_2
XFILLER_74_283 VGND VGND VPWR VPWR sky130_fd_sc_hd__decap_3
XFILLER_34_136 VGND VGND VPWR VPWR sky130_fd_sc_hd__decap_3
XFILLER_34_147 VGND VGND VPWR VPWR sky130_fd_sc_hd__decap_3
XFILLER_62_445 VGND VGND VPWR VPWR sky130_fd_sc_hd__fill_1
XFILLER_74_294 VGND VGND VPWR VPWR sky130_fd_sc_hd__decap_3
XFILLER_15_361 VGND VGND VPWR VPWR sky130_fd_sc_hd__decap_3
XFILLER_22_309 VGND VGND VPWR VPWR sky130_fd_sc_hd__decap_3
XFILLER_50_618 VGND VGND VPWR VPWR sky130_fd_sc_hd__decap_3
XFILLER_62_489 VGND VGND VPWR VPWR sky130_fd_sc_hd__decap_3
XTAP_TAPCELL_ROW_83_1251 VGND VPWR sky130_fd_sc_hd__tapvpwrvgnd_1
XFILLER_15_383 VGND VGND VPWR VPWR sky130_fd_sc_hd__fill_1
XFILLER_30_320 VGND VGND VPWR VPWR sky130_fd_sc_hd__decap_3
XFILLER_42_191 VGND VGND VPWR VPWR sky130_fd_sc_hd__decap_3
X_4620_ _4620_/A _5003_/A _4620_/C _5032_/A VGND VGND VPWR VPWR _4624_/B sky130_fd_sc_hd__and4_4
XFILLER_116_414 VGND VGND VPWR VPWR sky130_fd_sc_hd__decap_3
X_7270_ _7368_/CLK _7270_/D _6550_/Y VGND VGND VPWR VPWR _7270_/Q sky130_fd_sc_hd__dfrtp_2
X_4482_ _7338_/Q _4482_/A1 _4488_/S VGND VGND VPWR VPWR _7338_/D sky130_fd_sc_hd__mux2_2
X_3502_ _3502_/A _3502_/B _3485_/C VGND VGND VPWR VPWR _3502_/X sky130_fd_sc_hd__or3b_2
XFILLER_116_458 VGND VGND VPWR VPWR sky130_fd_sc_hd__decap_3
XFILLER_89_309 VGND VGND VPWR VPWR sky130_fd_sc_hd__decap_3
XFILLER_106_18 VGND VGND VPWR VPWR sky130_fd_sc_hd__decap_3
XTAP_TAPCELL_ROW_94_1380 VGND VPWR sky130_fd_sc_hd__tapvpwrvgnd_1
XFILLER_106_29 VGND VGND VPWR VPWR sky130_fd_sc_hd__decap_3
XFILLER_112_631 VGND VGND VPWR VPWR sky130_fd_sc_hd__decap_3
X_5103_ _5146_/B1 _5084_/B _5099_/X _5102_/X VGND VGND VPWR VPWR _5651_/A sky130_fd_sc_hd__a31oi_2
X_3364_ _3362_/X _5294_/B _3369_/A VGND VGND VPWR VPWR _3399_/B sky130_fd_sc_hd__a21boi_2
XFILLER_112_675 VGND VGND VPWR VPWR sky130_fd_sc_hd__decap_3
XFILLER_57_217 VGND VGND VPWR VPWR sky130_fd_sc_hd__decap_3
XFILLER_85_515 VGND VGND VPWR VPWR sky130_fd_sc_hd__fill_1
Xhold1205 _7323_/Q VGND VGND VPWR VPWR _4513_/A0 sky130_fd_sc_hd__dlygate4sd3_1
Xhold1216 _7306_/Q VGND VGND VPWR VPWR _4482_/A1 sky130_fd_sc_hd__dlygate4sd3_1
X_5034_ _5146_/B1 _5031_/X _5032_/Y _3618_/X _5033_/X VGND VGND VPWR VPWR _5658_/B
+ sky130_fd_sc_hd__a221o_2
XFILLER_38_442 VGND VGND VPWR VPWR sky130_fd_sc_hd__fill_1
XFILLER_38_464 VGND VGND VPWR VPWR sky130_fd_sc_hd__decap_3
XTAP_TAPCELL_ROW_56_919 VGND VPWR sky130_fd_sc_hd__tapvpwrvgnd_1
XFILLER_38_486 VGND VGND VPWR VPWR sky130_fd_sc_hd__decap_3
XFILLER_53_423 VGND VGND VPWR VPWR sky130_fd_sc_hd__decap_3
XFILLER_93_592 VGND VGND VPWR VPWR sky130_fd_sc_hd__decap_3
XTAP_TAPCELL_ROW_0_235 VGND VPWR sky130_fd_sc_hd__tapvpwrvgnd_1
X_6985_ _7397_/CLK _6985_/D _6265_/Y VGND VGND VPWR VPWR _6985_/Q sky130_fd_sc_hd__dfrtp_2
XTAP_TAPCELL_ROW_0_257 VGND VPWR sky130_fd_sc_hd__tapvpwrvgnd_1
XTAP_TAPCELL_ROW_0_246 VGND VPWR sky130_fd_sc_hd__tapvpwrvgnd_1
XFILLER_13_309 VGND VGND VPWR VPWR sky130_fd_sc_hd__decap_3
XFILLER_15_15 VGND VGND VPWR VPWR sky130_fd_sc_hd__decap_3
XFILLER_15_48 VGND VGND VPWR VPWR sky130_fd_sc_hd__decap_3
XFILLER_25_169 VGND VGND VPWR VPWR sky130_fd_sc_hd__decap_3
XFILLER_40_106 VGND VGND VPWR VPWR sky130_fd_sc_hd__decap_3
XFILLER_53_478 VGND VGND VPWR VPWR sky130_fd_sc_hd__fill_1
XFILLER_80_253 VGND VGND VPWR VPWR sky130_fd_sc_hd__decap_3
XFILLER_80_264 VGND VGND VPWR VPWR sky130_fd_sc_hd__decap_3
XTAP_TAPCELL_ROW_36_687 VGND VPWR sky130_fd_sc_hd__tapvpwrvgnd_1
XFILLER_21_331 VGND VGND VPWR VPWR sky130_fd_sc_hd__decap_3
XFILLER_21_353 VGND VGND VPWR VPWR sky130_fd_sc_hd__decap_3
X_4818_ _7002_/Q _4834_/A VGND VGND VPWR VPWR _4818_/Y sky130_fd_sc_hd__nand2_2
X_4749_ _7006_/Q _4749_/B VGND VGND VPWR VPWR _4750_/C sky130_fd_sc_hd__nor2_2
XFILLER_103_6 VGND VGND VPWR VPWR sky130_fd_sc_hd__decap_3
X_6419_ _6578_/A VGND VGND VPWR VPWR _6419_/Y sky130_fd_sc_hd__inv_2
X_7399_ _7401_/CLK _7399_/D _6679_/Y VGND VGND VPWR VPWR _7399_/Q sky130_fd_sc_hd__dfrtp_2
XFILLER_103_620 VGND VGND VPWR VPWR sky130_fd_sc_hd__fill_1
XFILLER_103_642 VGND VGND VPWR VPWR sky130_fd_sc_hd__decap_3
XFILLER_88_331 VGND VGND VPWR VPWR sky130_fd_sc_hd__decap_3
XTAP_TAPCELL_ROW_8_346 VGND VPWR sky130_fd_sc_hd__tapvpwrvgnd_1
XFILLER_0_268 VGND VGND VPWR VPWR sky130_fd_sc_hd__decap_3
XFILLER_88_375 VGND VGND VPWR VPWR sky130_fd_sc_hd__decap_3
XFILLER_56_22 VGND VGND VPWR VPWR sky130_fd_sc_hd__decap_3
XFILLER_76_548 VGND VGND VPWR VPWR sky130_fd_sc_hd__decap_3
XFILLER_63_209 VGND VGND VPWR VPWR sky130_fd_sc_hd__fill_1
XFILLER_17_615 VGND VGND VPWR VPWR sky130_fd_sc_hd__fill_1
XFILLER_29_486 VGND VGND VPWR VPWR sky130_fd_sc_hd__fill_1
XFILLER_56_250 VGND VGND VPWR VPWR sky130_fd_sc_hd__fill_2
XFILLER_56_77 VGND VGND VPWR VPWR sky130_fd_sc_hd__decap_3
XFILLER_84_570 VGND VGND VPWR VPWR sky130_fd_sc_hd__decap_3
XFILLER_84_592 VGND VGND VPWR VPWR sky130_fd_sc_hd__decap_3
XTAP_TAPCELL_ROW_106_1527 VGND VPWR sky130_fd_sc_hd__tapvpwrvgnd_1
XFILLER_112_50 VGND VGND VPWR VPWR sky130_fd_sc_hd__decap_3
XFILLER_16_147 VGND VGND VPWR VPWR sky130_fd_sc_hd__decap_3
XFILLER_44_434 VGND VGND VPWR VPWR sky130_fd_sc_hd__fill_2
XFILLER_71_220 VGND VGND VPWR VPWR sky130_fd_sc_hd__decap_3
XFILLER_112_83 VGND VGND VPWR VPWR sky130_fd_sc_hd__fill_1
XFILLER_112_94 VGND VGND VPWR VPWR sky130_fd_sc_hd__decap_3
XFILLER_31_128 VGND VGND VPWR VPWR sky130_fd_sc_hd__decap_3
XFILLER_72_54 VGND VGND VPWR VPWR sky130_fd_sc_hd__decap_3
XFILLER_12_342 VGND VGND VPWR VPWR sky130_fd_sc_hd__decap_3
XFILLER_24_191 VGND VGND VPWR VPWR sky130_fd_sc_hd__fill_1
XFILLER_40_662 VGND VGND VPWR VPWR sky130_fd_sc_hd__decap_3
XFILLER_12_397 VGND VGND VPWR VPWR sky130_fd_sc_hd__decap_3
XFILLER_8_368 VGND VGND VPWR VPWR sky130_fd_sc_hd__decap_3
XFILLER_21_80 VGND VGND VPWR VPWR sky130_fd_sc_hd__decap_3
XFILLER_4_530 VGND VGND VPWR VPWR sky130_fd_sc_hd__fill_2
XFILLER_113_428 VGND VGND VPWR VPWR sky130_fd_sc_hd__decap_3
XFILLER_98_117 VGND VGND VPWR VPWR sky130_fd_sc_hd__decap_3
XFILLER_106_491 VGND VGND VPWR VPWR sky130_fd_sc_hd__decap_3
XFILLER_79_331 VGND VGND VPWR VPWR sky130_fd_sc_hd__decap_3
XFILLER_97_73 VGND VGND VPWR VPWR sky130_fd_sc_hd__decap_3
XFILLER_39_206 VGND VGND VPWR VPWR sky130_fd_sc_hd__decap_3
XFILLER_97_95 VGND VGND VPWR VPWR sky130_fd_sc_hd__decap_3
XFILLER_39_228 VGND VGND VPWR VPWR sky130_fd_sc_hd__decap_3
XFILLER_79_386 VGND VGND VPWR VPWR sky130_fd_sc_hd__decap_3
XFILLER_94_312 VGND VGND VPWR VPWR sky130_fd_sc_hd__decap_3
XFILLER_82_507 VGND VGND VPWR VPWR sky130_fd_sc_hd__fill_2
XFILLER_82_518 VGND VGND VPWR VPWR sky130_fd_sc_hd__decap_3
XFILLER_94_345 VGND VGND VPWR VPWR sky130_fd_sc_hd__decap_3
XFILLER_90_551 VGND VGND VPWR VPWR sky130_fd_sc_hd__decap_3
XFILLER_22_106 VGND VGND VPWR VPWR sky130_fd_sc_hd__decap_3
XFILLER_62_253 VGND VGND VPWR VPWR sky130_fd_sc_hd__fill_2
XFILLER_62_264 VGND VGND VPWR VPWR sky130_fd_sc_hd__fill_1
X_6770_ _6959_/CLK _6770_/D VGND VGND VPWR VPWR _6770_/Q sky130_fd_sc_hd__dfxtp_2
XFILLER_22_139 VGND VGND VPWR VPWR sky130_fd_sc_hd__fill_1
XFILLER_62_297 VGND VGND VPWR VPWR sky130_fd_sc_hd__decap_3
XFILLER_90_595 VGND VGND VPWR VPWR sky130_fd_sc_hd__fill_2
X_5721_ _7366_/Q hold930/X _5721_/S VGND VGND VPWR VPWR _6710_/D sky130_fd_sc_hd__mux2_2
XTAP_TAPCELL_ROW_33_646 VGND VPWR sky130_fd_sc_hd__tapvpwrvgnd_1
XTAP_TAPCELL_ROW_61_988 VGND VPWR sky130_fd_sc_hd__tapvpwrvgnd_1
XPHY_EDGE_ROW_99_Left_216 VGND VGND VPWR VPWR sky130_fd_sc_hd__decap_3
XFILLER_30_161 VGND VGND VPWR VPWR sky130_fd_sc_hd__decap_3
XFILLER_31_673 VGND VGND VPWR VPWR sky130_fd_sc_hd__fill_2
X_5652_ _5664_/A VGND VGND VPWR VPWR _5652_/Y sky130_fd_sc_hd__inv_2
XFILLER_30_194 VGND VGND VPWR VPWR sky130_fd_sc_hd__fill_2
X_5583_ _5583_/A0 _5094_/X _5595_/B VGND VGND VPWR VPWR _7037_/D sky130_fd_sc_hd__mux2_2
X_4603_ _4603_/A1 _4577_/B _3487_/X VGND VGND VPWR VPWR _7279_/D sky130_fd_sc_hd__a21o_2
XFILLER_116_200 VGND VGND VPWR VPWR sky130_fd_sc_hd__decap_3
XFILLER_116_222 VGND VGND VPWR VPWR sky130_fd_sc_hd__fill_2
XFILLER_7_60 VGND VGND VPWR VPWR sky130_fd_sc_hd__decap_3
X_7322_ _7322_/CLK _7322_/D _6602_/Y VGND VGND VPWR VPWR _7322_/Q sky130_fd_sc_hd__dfrtp_2
X_4534_ _4534_/A0 _7280_/Q _4534_/S VGND VGND VPWR VPWR _7312_/D sky130_fd_sc_hd__mux2_2
XFILLER_7_390 VGND VGND VPWR VPWR sky130_fd_sc_hd__fill_2
XFILLER_7_93 VGND VGND VPWR VPWR sky130_fd_sc_hd__decap_3
XFILLER_104_417 VGND VGND VPWR VPWR sky130_fd_sc_hd__decap_3
X_7253_ _7279_/CLK _7253_/D _6533_/Y VGND VGND VPWR VPWR _7253_/Q sky130_fd_sc_hd__dfrtp_2
X_4465_ _5655_/B _5655_/C VGND VGND VPWR VPWR _5650_/A sky130_fd_sc_hd__nor2_2
X_7184_ _7386_/CLK _7184_/D _6464_/Y VGND VGND VPWR VPWR _7184_/Q sky130_fd_sc_hd__dfrtp_2
X_4396_ _4396_/A _4444_/B VGND VGND VPWR VPWR _4648_/A sky130_fd_sc_hd__nor2_2
X_3347_ _5640_/B _3509_/B VGND VGND VPWR VPWR _3420_/A sky130_fd_sc_hd__or2_2
XTAP_TAPCELL_ROW_5_316 VGND VPWR sky130_fd_sc_hd__tapvpwrvgnd_1
XFILLER_100_645 VGND VGND VPWR VPWR sky130_fd_sc_hd__decap_3
XFILLER_85_312 VGND VGND VPWR VPWR sky130_fd_sc_hd__decap_3
XFILLER_97_172 VGND VGND VPWR VPWR sky130_fd_sc_hd__fill_1
Xhold1002 _7383_/Q VGND VGND VPWR VPWR _3875_/A1 sky130_fd_sc_hd__dlygate4sd3_1
Xhold1013 _7399_/Q VGND VGND VPWR VPWR _3710_/A1 sky130_fd_sc_hd__dlygate4sd3_1
Xhold1024 _7257_/Q VGND VGND VPWR VPWR _5080_/A0 sky130_fd_sc_hd__dlygate4sd3_1
XFILLER_100_678 VGND VGND VPWR VPWR sky130_fd_sc_hd__decap_3
XFILLER_73_518 VGND VGND VPWR VPWR sky130_fd_sc_hd__decap_3
Xhold1035 _7313_/Q VGND VGND VPWR VPWR _4532_/A0 sky130_fd_sc_hd__dlygate4sd3_1
Xhold1046 _7229_/Q VGND VGND VPWR VPWR _5198_/A sky130_fd_sc_hd__dlygate4sd3_1
Xhold1057 _7342_/Q VGND VGND VPWR VPWR _4474_/A0 sky130_fd_sc_hd__dlygate4sd3_1
X_5017_ _5018_/A _5017_/B VGND VGND VPWR VPWR _5017_/Y sky130_fd_sc_hd__xnor2_2
Xhold1068 _7223_/Q VGND VGND VPWR VPWR _5211_/A sky130_fd_sc_hd__dlygate4sd3_1
Xhold1079 _7241_/Q VGND VGND VPWR VPWR _5173_/A sky130_fd_sc_hd__dlygate4sd3_1
XFILLER_53_231 VGND VGND VPWR VPWR sky130_fd_sc_hd__decap_3
XFILLER_66_592 VGND VGND VPWR VPWR sky130_fd_sc_hd__decap_3
XFILLER_81_540 VGND VGND VPWR VPWR sky130_fd_sc_hd__decap_3
XFILLER_26_58 VGND VGND VPWR VPWR sky130_fd_sc_hd__decap_3
XFILLER_53_264 VGND VGND VPWR VPWR sky130_fd_sc_hd__decap_3
XFILLER_81_584 VGND VGND VPWR VPWR sky130_fd_sc_hd__decap_3
XFILLER_53_297 VGND VGND VPWR VPWR sky130_fd_sc_hd__fill_1
X_6968_ _6976_/CLK _6968_/D VGND VGND VPWR VPWR _6968_/Q sky130_fd_sc_hd__dfxtp_2
XFILLER_42_24 VGND VGND VPWR VPWR sky130_fd_sc_hd__decap_3
X_6899_ _6964_/CLK _6899_/D VGND VGND VPWR VPWR _6899_/Q sky130_fd_sc_hd__dfxtp_2
XFILLER_21_161 VGND VGND VPWR VPWR sky130_fd_sc_hd__decap_3
XFILLER_21_172 VGND VGND VPWR VPWR sky130_fd_sc_hd__decap_3
XFILLER_42_46 VGND VGND VPWR VPWR sky130_fd_sc_hd__decap_3
XTAP_TAPCELL_ROW_101_1468 VGND VPWR sky130_fd_sc_hd__tapvpwrvgnd_1
XFILLER_107_211 VGND VGND VPWR VPWR sky130_fd_sc_hd__decap_3
XFILLER_5_305 VGND VGND VPWR VPWR sky130_fd_sc_hd__decap_3
XFILLER_107_50 VGND VGND VPWR VPWR sky130_fd_sc_hd__decap_3
XFILLER_3_18 VGND VGND VPWR VPWR sky130_fd_sc_hd__decap_3
Xhold880 _7075_/Q VGND VGND VPWR VPWR _7075_/D sky130_fd_sc_hd__dlygate4sd3_1
Xhold891 _7067_/Q VGND VGND VPWR VPWR _7067_/D sky130_fd_sc_hd__dlygate4sd3_1
XFILLER_107_72 VGND VGND VPWR VPWR sky130_fd_sc_hd__decap_3
XFILLER_67_21 VGND VGND VPWR VPWR sky130_fd_sc_hd__decap_3
XFILLER_76_301 VGND VGND VPWR VPWR sky130_fd_sc_hd__decap_3
XFILLER_89_673 VGND VGND VPWR VPWR sky130_fd_sc_hd__decap_3
XFILLER_103_472 VGND VGND VPWR VPWR sky130_fd_sc_hd__decap_3
XFILLER_103_494 VGND VGND VPWR VPWR sky130_fd_sc_hd__decap_3
XFILLER_67_54 VGND VGND VPWR VPWR sky130_fd_sc_hd__fill_2
XFILLER_76_312 VGND VGND VPWR VPWR sky130_fd_sc_hd__decap_3
XFILLER_88_183 VGND VGND VPWR VPWR sky130_fd_sc_hd__decap_3
XTAP_TAPCELL_ROW_112_1597 VGND VPWR sky130_fd_sc_hd__tapvpwrvgnd_1
XFILLER_64_507 VGND VGND VPWR VPWR sky130_fd_sc_hd__fill_2
XFILLER_36_209 VGND VGND VPWR VPWR sky130_fd_sc_hd__fill_1
XFILLER_64_529 VGND VGND VPWR VPWR sky130_fd_sc_hd__decap_3
XFILLER_17_434 VGND VGND VPWR VPWR sky130_fd_sc_hd__decap_3
XFILLER_57_592 VGND VGND VPWR VPWR sky130_fd_sc_hd__decap_3
XFILLER_91_337 VGND VGND VPWR VPWR sky130_fd_sc_hd__fill_2
XFILLER_32_404 VGND VGND VPWR VPWR sky130_fd_sc_hd__decap_3
XFILLER_44_253 VGND VGND VPWR VPWR sky130_fd_sc_hd__fill_1
XFILLER_72_573 VGND VGND VPWR VPWR sky130_fd_sc_hd__decap_3
XFILLER_83_86 VGND VGND VPWR VPWR sky130_fd_sc_hd__decap_3
XTAP_TAPCELL_ROW_67_1054 VGND VPWR sky130_fd_sc_hd__tapvpwrvgnd_1
XFILLER_16_80 VGND VGND VPWR VPWR sky130_fd_sc_hd__decap_3
XFILLER_44_275 VGND VGND VPWR VPWR sky130_fd_sc_hd__decap_3
XTAP_TAPCELL_ROW_80_1210 VGND VPWR sky130_fd_sc_hd__tapvpwrvgnd_1
XFILLER_13_662 VGND VGND VPWR VPWR sky130_fd_sc_hd__fill_2
XFILLER_13_673 VGND VGND VPWR VPWR sky130_fd_sc_hd__decap_3
XTAP_TAPCELL_ROW_30_616 VGND VPWR sky130_fd_sc_hd__tapvpwrvgnd_1
XFILLER_8_132 VGND VGND VPWR VPWR sky130_fd_sc_hd__decap_3
XFILLER_66_6 VGND VGND VPWR VPWR sky130_fd_sc_hd__decap_3
XTAP_TAPCELL_ROW_10_373 VGND VPWR sky130_fd_sc_hd__tapvpwrvgnd_1
XFILLER_113_214 VGND VGND VPWR VPWR sky130_fd_sc_hd__decap_3
XTAP_TAPCELL_ROW_78_1183 VGND VPWR sky130_fd_sc_hd__tapvpwrvgnd_1
XFILLER_99_404 VGND VGND VPWR VPWR sky130_fd_sc_hd__decap_3
XFILLER_113_225 VGND VGND VPWR VPWR sky130_fd_sc_hd__decap_3
X_4250_ _7101_/Q _4351_/A2 _4267_/B1 _7165_/Q VGND VGND VPWR VPWR _4250_/X sky130_fd_sc_hd__a22o_2
XFILLER_99_459 VGND VGND VPWR VPWR sky130_fd_sc_hd__decap_3
XFILLER_99_437 VGND VGND VPWR VPWR sky130_fd_sc_hd__fill_2
X_4181_ _7200_/Q _4268_/A2 _4354_/B1 _7392_/Q VGND VGND VPWR VPWR _4181_/X sky130_fd_sc_hd__a22o_2
XFILLER_67_312 VGND VGND VPWR VPWR sky130_fd_sc_hd__decap_3
XFILLER_79_161 VGND VGND VPWR VPWR sky130_fd_sc_hd__decap_3
XFILLER_79_172 VGND VGND VPWR VPWR sky130_fd_sc_hd__decap_3
XFILLER_95_665 VGND VGND VPWR VPWR sky130_fd_sc_hd__decap_3
XFILLER_95_676 VGND VGND VPWR VPWR sky130_fd_sc_hd__decap_3
XFILLER_27_209 VGND VGND VPWR VPWR sky130_fd_sc_hd__decap_3
XFILLER_82_315 VGND VGND VPWR VPWR sky130_fd_sc_hd__decap_3
XFILLER_94_164 VGND VGND VPWR VPWR sky130_fd_sc_hd__decap_3
XTAP_TAPCELL_ROW_38_705 VGND VPWR sky130_fd_sc_hd__tapvpwrvgnd_1
XFILLER_35_220 VGND VGND VPWR VPWR sky130_fd_sc_hd__decap_3
XFILLER_82_348 VGND VGND VPWR VPWR sky130_fd_sc_hd__decap_3
XFILLER_35_253 VGND VGND VPWR VPWR sky130_fd_sc_hd__decap_3
X_6822_ _6972_/CLK _6822_/D VGND VGND VPWR VPWR _6822_/Q sky130_fd_sc_hd__dfxtp_2
XFILLER_35_275 VGND VGND VPWR VPWR sky130_fd_sc_hd__decap_3
XFILLER_50_223 VGND VGND VPWR VPWR sky130_fd_sc_hd__fill_2
XTAP_TAPCELL_ROW_18_473 VGND VPWR sky130_fd_sc_hd__tapvpwrvgnd_1
XTAP_TAPCELL_ROW_18_462 VGND VPWR sky130_fd_sc_hd__tapvpwrvgnd_1
XFILLER_50_256 VGND VGND VPWR VPWR sky130_fd_sc_hd__decap_3
X_6753_ _6964_/CLK _6753_/D VGND VGND VPWR VPWR _6753_/Q sky130_fd_sc_hd__dfxtp_2
X_6684_ _6684_/A VGND VGND VPWR VPWR _6684_/Y sky130_fd_sc_hd__inv_2
X_3896_ _3880_/X _3885_/X _3895_/X _3896_/B1 VGND VGND VPWR VPWR _3896_/Y sky130_fd_sc_hd__o31ai_2
XFILLER_12_27 VGND VGND VPWR VPWR sky130_fd_sc_hd__fill_1
XFILLER_12_38 VGND VGND VPWR VPWR sky130_fd_sc_hd__decap_3
X_5566_ hold988/X _5015_/A _4860_/Y VGND VGND VPWR VPWR _7051_/D sky130_fd_sc_hd__o21a_2
XFILLER_104_203 VGND VGND VPWR VPWR sky130_fd_sc_hd__decap_3
X_7305_ _7369_/CLK _7305_/D _6585_/Y VGND VGND VPWR VPWR _7305_/Q sky130_fd_sc_hd__dfrtp_2
X_4517_ _4517_/A0 _7289_/Q _4517_/S VGND VGND VPWR VPWR _7321_/D sky130_fd_sc_hd__mux2_2
X_7236_ _7264_/CLK _7236_/D _6516_/Y VGND VGND VPWR VPWR _7236_/Q sky130_fd_sc_hd__dfrtp_2
X_4448_ _4444_/X _4447_/Y _4413_/A VGND VGND VPWR VPWR _4448_/X sky130_fd_sc_hd__o21a_2
XFILLER_58_312 VGND VGND VPWR VPWR sky130_fd_sc_hd__decap_3
XFILLER_86_621 VGND VGND VPWR VPWR sky130_fd_sc_hd__decap_3
X_7167_ _7264_/CLK _7167_/D _6447_/Y VGND VGND VPWR VPWR _7167_/Q sky130_fd_sc_hd__dfrtp_2
X_4379_ _4938_/B _4379_/B VGND VGND VPWR VPWR _4937_/A sky130_fd_sc_hd__or2_2
XFILLER_98_470 VGND VGND VPWR VPWR sky130_fd_sc_hd__decap_3
XFILLER_100_442 VGND VGND VPWR VPWR sky130_fd_sc_hd__decap_3
XFILLER_112_291 VGND VGND VPWR VPWR sky130_fd_sc_hd__decap_3
XFILLER_37_24 VGND VGND VPWR VPWR sky130_fd_sc_hd__decap_3
XFILLER_58_356 VGND VGND VPWR VPWR sky130_fd_sc_hd__decap_3
XFILLER_85_131 VGND VGND VPWR VPWR sky130_fd_sc_hd__fill_2
XFILLER_86_654 VGND VGND VPWR VPWR sky130_fd_sc_hd__fill_2
XFILLER_86_665 VGND VGND VPWR VPWR sky130_fd_sc_hd__decap_3
X_7098_ _7279_/CLK _7098_/D _6378_/Y VGND VGND VPWR VPWR _7098_/Q sky130_fd_sc_hd__dfrtp_2
XFILLER_100_464 VGND VGND VPWR VPWR sky130_fd_sc_hd__decap_3
XFILLER_100_486 VGND VGND VPWR VPWR sky130_fd_sc_hd__decap_3
XFILLER_73_337 VGND VGND VPWR VPWR sky130_fd_sc_hd__decap_3
XFILLER_26_242 VGND VGND VPWR VPWR sky130_fd_sc_hd__decap_3
XFILLER_26_253 VGND VGND VPWR VPWR sky130_fd_sc_hd__decap_3
XFILLER_26_286 VGND VGND VPWR VPWR sky130_fd_sc_hd__decap_3
XFILLER_41_201 VGND VGND VPWR VPWR sky130_fd_sc_hd__decap_3
XFILLER_53_45 VGND VGND VPWR VPWR sky130_fd_sc_hd__decap_3
XFILLER_54_595 VGND VGND VPWR VPWR sky130_fd_sc_hd__decap_3
XFILLER_81_370 VGND VGND VPWR VPWR sky130_fd_sc_hd__decap_3
XFILLER_41_234 VGND VGND VPWR VPWR sky130_fd_sc_hd__decap_3
XFILLER_6_603 VGND VGND VPWR VPWR sky130_fd_sc_hd__decap_3
XFILLER_5_102 VGND VGND VPWR VPWR sky130_fd_sc_hd__decap_3
XFILLER_5_113 VGND VGND VPWR VPWR sky130_fd_sc_hd__decap_3
XFILLER_6_669 VGND VGND VPWR VPWR sky130_fd_sc_hd__decap_3
XFILLER_108_586 VGND VGND VPWR VPWR sky130_fd_sc_hd__fill_2
XFILLER_5_157 VGND VGND VPWR VPWR sky130_fd_sc_hd__decap_3
XTAP_TAPCELL_ROW_114_1615 VGND VPWR sky130_fd_sc_hd__tapvpwrvgnd_1
XFILLER_78_20 VGND VGND VPWR VPWR sky130_fd_sc_hd__decap_3
XFILLER_110_206 VGND VGND VPWR VPWR sky130_fd_sc_hd__decap_3
XFILLER_78_53 VGND VGND VPWR VPWR sky130_fd_sc_hd__decap_3
XFILLER_78_64 VGND VGND VPWR VPWR sky130_fd_sc_hd__decap_3
XFILLER_96_418 VGND VGND VPWR VPWR sky130_fd_sc_hd__fill_2
XFILLER_49_312 VGND VGND VPWR VPWR sky130_fd_sc_hd__decap_3
XFILLER_49_323 VGND VGND VPWR VPWR sky130_fd_sc_hd__decap_3
XFILLER_77_632 VGND VGND VPWR VPWR sky130_fd_sc_hd__fill_1
XFILLER_78_97 VGND VGND VPWR VPWR sky130_fd_sc_hd__fill_1
XFILLER_1_396 VGND VGND VPWR VPWR sky130_fd_sc_hd__decap_3
XFILLER_49_356 VGND VGND VPWR VPWR sky130_fd_sc_hd__decap_3
XFILLER_77_665 VGND VGND VPWR VPWR sky130_fd_sc_hd__decap_3
XFILLER_64_315 VGND VGND VPWR VPWR sky130_fd_sc_hd__decap_3
XFILLER_76_175 VGND VGND VPWR VPWR sky130_fd_sc_hd__decap_3
XFILLER_77_676 VGND VGND VPWR VPWR sky130_fd_sc_hd__decap_3
XFILLER_92_657 VGND VGND VPWR VPWR sky130_fd_sc_hd__decap_3
XFILLER_94_85 VGND VGND VPWR VPWR sky130_fd_sc_hd__fill_2
XFILLER_17_231 VGND VGND VPWR VPWR sky130_fd_sc_hd__decap_3
XFILLER_17_264 VGND VGND VPWR VPWR sky130_fd_sc_hd__decap_3
XFILLER_32_212 VGND VGND VPWR VPWR sky130_fd_sc_hd__decap_3
XFILLER_60_510 VGND VGND VPWR VPWR sky130_fd_sc_hd__decap_3
XFILLER_32_256 VGND VGND VPWR VPWR sky130_fd_sc_hd__decap_3
XTAP_TAPCELL_ROW_15_432 VGND VPWR sky130_fd_sc_hd__tapvpwrvgnd_1
XFILLER_60_587 VGND VGND VPWR VPWR sky130_fd_sc_hd__fill_1
XFILLER_60_598 VGND VGND VPWR VPWR sky130_fd_sc_hd__decap_3
X_3750_ hold978/X _4466_/A wire552/X VGND VGND VPWR VPWR _7398_/D sky130_fd_sc_hd__a21bo_2
XTAP_TAPCELL_ROW_43_763 VGND VPWR sky130_fd_sc_hd__tapvpwrvgnd_1
XFILLER_13_492 VGND VGND VPWR VPWR sky130_fd_sc_hd__decap_3
XFILLER_9_430 VGND VGND VPWR VPWR sky130_fd_sc_hd__fill_1
X_3681_ _3674_/Y _3913_/A2 _5660_/B _3676_/Y _3680_/X VGND VGND VPWR VPWR _3682_/B
+ sky130_fd_sc_hd__a221o_2
XFILLER_64_3 VGND VGND VPWR VPWR sky130_fd_sc_hd__decap_3
XFILLER_114_501 VGND VGND VPWR VPWR sky130_fd_sc_hd__decap_3
XFILLER_5_691 VGND VGND VPWR VPWR sky130_fd_sc_hd__fill_1
X_5282_ _5282_/A1 _5238_/X _3610_/Y VGND VGND VPWR VPWR _7189_/D sky130_fd_sc_hd__a21o_2
X_4302_ _7224_/Q _4340_/A2 _3556_/A _4301_/X VGND VGND VPWR VPWR _4302_/X sky130_fd_sc_hd__a211o_2
XFILLER_99_245 VGND VGND VPWR VPWR sky130_fd_sc_hd__decap_3
XFILLER_114_578 VGND VGND VPWR VPWR sky130_fd_sc_hd__decap_3
XFILLER_4_50 VGND VGND VPWR VPWR sky130_fd_sc_hd__decap_3
XFILLER_87_418 VGND VGND VPWR VPWR sky130_fd_sc_hd__decap_3
X_7021_ _7365_/CLK _7021_/D _6301_/Y VGND VGND VPWR VPWR _7021_/Q sky130_fd_sc_hd__dfrtp_2
X_4233_ _7323_/Q _3979_/S _4530_/S _7291_/Q VGND VGND VPWR VPWR _4233_/X sky130_fd_sc_hd__a22o_2
XFILLER_99_278 VGND VGND VPWR VPWR sky130_fd_sc_hd__fill_2
XFILLER_99_267 VGND VGND VPWR VPWR sky130_fd_sc_hd__decap_3
XFILLER_101_217 VGND VGND VPWR VPWR sky130_fd_sc_hd__decap_3
XFILLER_114_589 VGND VGND VPWR VPWR sky130_fd_sc_hd__decap_3
XFILLER_4_83 VGND VGND VPWR VPWR sky130_fd_sc_hd__fill_1
XFILLER_4_94 VGND VGND VPWR VPWR sky130_fd_sc_hd__decap_3
XFILLER_114_18 VGND VGND VPWR VPWR sky130_fd_sc_hd__decap_3
XFILLER_114_29 VGND VGND VPWR VPWR sky130_fd_sc_hd__decap_3
XFILLER_68_643 VGND VGND VPWR VPWR sky130_fd_sc_hd__fill_1
XFILLER_68_654 VGND VGND VPWR VPWR sky130_fd_sc_hd__decap_3
X_4164_ _7105_/Q _4351_/A2 _4267_/B1 _7169_/Q VGND VGND VPWR VPWR _4164_/X sky130_fd_sc_hd__a22o_2
XFILLER_67_164 VGND VGND VPWR VPWR sky130_fd_sc_hd__decap_3
XFILLER_83_602 VGND VGND VPWR VPWR sky130_fd_sc_hd__decap_3
XFILLER_95_473 VGND VGND VPWR VPWR sky130_fd_sc_hd__decap_3
X_4095_ _4095_/A _4210_/B VGND VGND VPWR VPWR _4096_/B sky130_fd_sc_hd__nand2_2
XFILLER_55_337 VGND VGND VPWR VPWR sky130_fd_sc_hd__decap_3
XFILLER_67_186 VGND VGND VPWR VPWR sky130_fd_sc_hd__fill_1
XFILLER_82_112 VGND VGND VPWR VPWR sky130_fd_sc_hd__decap_3
XFILLER_82_156 VGND VGND VPWR VPWR sky130_fd_sc_hd__decap_3
XFILLER_83_679 VGND VGND VPWR VPWR sky130_fd_sc_hd__decap_3
XFILLER_23_201 VGND VGND VPWR VPWR sky130_fd_sc_hd__decap_3
XFILLER_36_595 VGND VGND VPWR VPWR sky130_fd_sc_hd__fill_1
XFILLER_63_370 VGND VGND VPWR VPWR sky130_fd_sc_hd__decap_3
XFILLER_23_234 VGND VGND VPWR VPWR sky130_fd_sc_hd__fill_1
XFILLER_23_256 VGND VGND VPWR VPWR sky130_fd_sc_hd__decap_3
Xplace381 wire566/X VGND VGND VPWR VPWR _4235_/B1 sky130_fd_sc_hd__buf_2
Xplace370 _5151_/A VGND VGND VPWR VPWR _3896_/B1 sky130_fd_sc_hd__buf_2
X_6805_ _7005_/CLK _6805_/D VGND VGND VPWR VPWR _6805_/Q sky130_fd_sc_hd__dfxtp_2
XFILLER_23_15 VGND VGND VPWR VPWR sky130_fd_sc_hd__decap_3
XFILLER_51_598 VGND VGND VPWR VPWR sky130_fd_sc_hd__decap_3
Xplace392 _3326_/A VGND VGND VPWR VPWR _5648_/A sky130_fd_sc_hd__buf_2
X_6736_ _6977_/CLK _6736_/D VGND VGND VPWR VPWR _6736_/Q sky130_fd_sc_hd__dfxtp_2
X_4997_ _4997_/A1 _6992_/D _4983_/X _4996_/X VGND VGND VPWR VPWR _4997_/X sky130_fd_sc_hd__a211o_2
XFILLER_23_48 VGND VGND VPWR VPWR sky130_fd_sc_hd__fill_2
XFILLER_109_306 VGND VGND VPWR VPWR sky130_fd_sc_hd__decap_3
X_6667_ _6672_/A VGND VGND VPWR VPWR _6667_/Y sky130_fd_sc_hd__inv_2
X_3879_ _6747_/Q _3879_/A2 _3891_/A2 _6735_/Q _3878_/X VGND VGND VPWR VPWR _3879_/X
+ sky130_fd_sc_hd__a221o_2
X_6598_ _6599_/A VGND VGND VPWR VPWR _6598_/Y sky130_fd_sc_hd__inv_2
XFILLER_3_617 VGND VGND VPWR VPWR sky130_fd_sc_hd__fill_1
XFILLER_105_523 VGND VGND VPWR VPWR sky130_fd_sc_hd__fill_2
XFILLER_105_534 VGND VGND VPWR VPWR sky130_fd_sc_hd__decap_3
XFILLER_2_127 VGND VGND VPWR VPWR sky130_fd_sc_hd__decap_3
XFILLER_105_567 VGND VGND VPWR VPWR sky130_fd_sc_hd__decap_3
XFILLER_78_418 VGND VGND VPWR VPWR sky130_fd_sc_hd__fill_2
XFILLER_59_610 VGND VGND VPWR VPWR sky130_fd_sc_hd__decap_3
XFILLER_59_632 VGND VGND VPWR VPWR sky130_fd_sc_hd__decap_3
X_7219_ clkload6/A _7219_/D _6499_/Y VGND VGND VPWR VPWR _7219_/Q sky130_fd_sc_hd__dfrtp_2
XFILLER_58_131 VGND VGND VPWR VPWR sky130_fd_sc_hd__decap_3
XFILLER_59_665 VGND VGND VPWR VPWR sky130_fd_sc_hd__decap_3
XFILLER_86_451 VGND VGND VPWR VPWR sky130_fd_sc_hd__decap_3
XFILLER_48_78 VGND VGND VPWR VPWR sky130_fd_sc_hd__decap_3
XFILLER_58_153 VGND VGND VPWR VPWR sky130_fd_sc_hd__fill_1
XFILLER_59_676 VGND VGND VPWR VPWR sky130_fd_sc_hd__decap_3
XFILLER_74_613 VGND VGND VPWR VPWR sky130_fd_sc_hd__decap_3
XFILLER_46_326 VGND VGND VPWR VPWR sky130_fd_sc_hd__decap_3
XFILLER_58_186 VGND VGND VPWR VPWR sky130_fd_sc_hd__decap_3
XFILLER_58_197 VGND VGND VPWR VPWR sky130_fd_sc_hd__decap_3
XFILLER_86_495 VGND VGND VPWR VPWR sky130_fd_sc_hd__decap_3
XFILLER_64_44 VGND VGND VPWR VPWR sky130_fd_sc_hd__fill_1
XFILLER_14_212 VGND VGND VPWR VPWR sky130_fd_sc_hd__decap_3
XFILLER_61_329 VGND VGND VPWR VPWR sky130_fd_sc_hd__decap_3
XFILLER_64_77 VGND VGND VPWR VPWR sky130_fd_sc_hd__decap_3
XFILLER_73_189 VGND VGND VPWR VPWR sky130_fd_sc_hd__decap_3
XFILLER_82_690 VGND VGND VPWR VPWR sky130_fd_sc_hd__fill_2
XTAP_TAPCELL_ROW_64_1024 VGND VPWR sky130_fd_sc_hd__tapvpwrvgnd_1
XFILLER_14_256 VGND VGND VPWR VPWR sky130_fd_sc_hd__decap_3
XFILLER_54_392 VGND VGND VPWR VPWR sky130_fd_sc_hd__decap_3
XFILLER_42_587 VGND VGND VPWR VPWR sky130_fd_sc_hd__fill_1
XFILLER_80_32 VGND VGND VPWR VPWR sky130_fd_sc_hd__decap_3
XFILLER_9_39 VGND VGND VPWR VPWR sky130_fd_sc_hd__decap_3
XFILLER_80_65 VGND VGND VPWR VPWR sky130_fd_sc_hd__decap_3
Xfanout60 _6587_/A VGND VGND VPWR VPWR _6616_/A sky130_fd_sc_hd__buf_2
Xfanout71 fanout72/X VGND VGND VPWR VPWR _6395_/A sky130_fd_sc_hd__buf_1
XTAP_TAPCELL_ROW_40_733 VGND VPWR sky130_fd_sc_hd__tapvpwrvgnd_1
XFILLER_108_361 VGND VGND VPWR VPWR sky130_fd_sc_hd__decap_3
XFILLER_6_477 VGND VGND VPWR VPWR sky130_fd_sc_hd__fill_2
XTAP_TAPCELL_ROW_20_490 VGND VPWR sky130_fd_sc_hd__tapvpwrvgnd_1
XFILLER_89_63 VGND VGND VPWR VPWR sky130_fd_sc_hd__decap_3
XTAP_TAPCELL_ROW_75_1153 VGND VPWR sky130_fd_sc_hd__tapvpwrvgnd_1
XFILLER_69_418 VGND VGND VPWR VPWR sky130_fd_sc_hd__decap_3
XFILLER_89_96 VGND VGND VPWR VPWR sky130_fd_sc_hd__decap_3
XFILLER_111_526 VGND VGND VPWR VPWR sky130_fd_sc_hd__decap_3
XFILLER_2_672 VGND VGND VPWR VPWR sky130_fd_sc_hd__decap_3
XFILLER_96_237 VGND VGND VPWR VPWR sky130_fd_sc_hd__decap_3
XFILLER_29_6 VGND VGND VPWR VPWR sky130_fd_sc_hd__decap_3
XFILLER_77_440 VGND VGND VPWR VPWR sky130_fd_sc_hd__decap_3
XFILLER_49_164 VGND VGND VPWR VPWR sky130_fd_sc_hd__decap_3
XFILLER_77_473 VGND VGND VPWR VPWR sky130_fd_sc_hd__decap_3
XFILLER_37_337 VGND VGND VPWR VPWR sky130_fd_sc_hd__fill_1
XFILLER_49_186 VGND VGND VPWR VPWR sky130_fd_sc_hd__decap_3
XFILLER_64_112 VGND VGND VPWR VPWR sky130_fd_sc_hd__fill_1
XFILLER_65_635 VGND VGND VPWR VPWR sky130_fd_sc_hd__decap_3
XFILLER_92_421 VGND VGND VPWR VPWR sky130_fd_sc_hd__decap_3
XFILLER_92_443 VGND VGND VPWR VPWR sky130_fd_sc_hd__decap_3
XTAP_TAPCELL_ROW_48_833 VGND VPWR sky130_fd_sc_hd__tapvpwrvgnd_1
XTAP_TAPCELL_ROW_48_822 VGND VPWR sky130_fd_sc_hd__tapvpwrvgnd_1
XFILLER_52_307 VGND VGND VPWR VPWR sky130_fd_sc_hd__fill_1
XFILLER_65_668 VGND VGND VPWR VPWR sky130_fd_sc_hd__decap_3
XFILLER_65_679 VGND VGND VPWR VPWR sky130_fd_sc_hd__decap_3
XFILLER_18_584 VGND VGND VPWR VPWR sky130_fd_sc_hd__decap_3
XFILLER_52_318 VGND VGND VPWR VPWR sky130_fd_sc_hd__decap_3
X_4920_ _4920_/A _4920_/B VGND VGND VPWR VPWR _4920_/Y sky130_fd_sc_hd__xnor2_2
XTAP_TAPCELL_ROW_86_1282 VGND VPWR sky130_fd_sc_hd__tapvpwrvgnd_1
XFILLER_33_532 VGND VGND VPWR VPWR sky130_fd_sc_hd__decap_3
X_4851_ _4633_/A _4142_/X _4849_/Y _4850_/Y _4969_/B VGND VGND VPWR VPWR _4855_/B
+ sky130_fd_sc_hd__o311a_2
XTAP_TAPCELL_ROW_28_590 VGND VPWR sky130_fd_sc_hd__tapvpwrvgnd_1
XFILLER_60_351 VGND VGND VPWR VPWR sky130_fd_sc_hd__decap_3
X_3802_ _3733_/X _3794_/X _3796_/X _3746_/X _3801_/X VGND VGND VPWR VPWR _3802_/X
+ sky130_fd_sc_hd__a221o_2
X_4782_ _4413_/A _4444_/X _4780_/Y _4969_/B VGND VGND VPWR VPWR _4782_/Y sky130_fd_sc_hd__o31ai_2
XPHY_EDGE_ROW_72_Left_189 VGND VGND VPWR VPWR sky130_fd_sc_hd__decap_3
X_6521_ _6587_/A VGND VGND VPWR VPWR _6521_/Y sky130_fd_sc_hd__inv_2
X_3733_ _3746_/A _3741_/B _3733_/C VGND VGND VPWR VPWR _3733_/X sky130_fd_sc_hd__and3_2
XFILLER_109_18 VGND VGND VPWR VPWR sky130_fd_sc_hd__decap_3
X_6452_ _6610_/A VGND VGND VPWR VPWR _6452_/Y sky130_fd_sc_hd__inv_2
XFILLER_106_309 VGND VGND VPWR VPWR sky130_fd_sc_hd__decap_3
Xclkload30 _7341_/CLK VGND VGND VPWR VPWR clkload30/Y sky130_fd_sc_hd__clkinv_2
X_6383_ _6548_/A VGND VGND VPWR VPWR _6383_/Y sky130_fd_sc_hd__inv_2
X_3595_ _4292_/A _3594_/B _3594_/Y _5020_/A VGND VGND VPWR VPWR _3614_/A sky130_fd_sc_hd__a211o_2
XFILLER_114_353 VGND VGND VPWR VPWR sky130_fd_sc_hd__decap_3
XFILLER_114_375 VGND VGND VPWR VPWR sky130_fd_sc_hd__decap_3
XPHY_EDGE_ROW_81_Left_198 VGND VGND VPWR VPWR sky130_fd_sc_hd__decap_3
XFILLER_102_548 VGND VGND VPWR VPWR sky130_fd_sc_hd__decap_3
XFILLER_68_440 VGND VGND VPWR VPWR sky130_fd_sc_hd__decap_3
X_7004_ _7005_/CLK _7004_/D _6284_/Y VGND VGND VPWR VPWR _7004_/Q sky130_fd_sc_hd__dfrtp_2
X_5196_ _5196_/A _5217_/B VGND VGND VPWR VPWR _7230_/D sky130_fd_sc_hd__and2_2
X_4216_ _7068_/Q _4265_/B _4460_/A VGND VGND VPWR VPWR _4371_/B sky130_fd_sc_hd__o21a_2
XFILLER_18_15 VGND VGND VPWR VPWR sky130_fd_sc_hd__decap_3
XFILLER_56_624 VGND VGND VPWR VPWR sky130_fd_sc_hd__decap_3
X_4147_ _7266_/Q _4422_/A2 _3958_/S _7330_/Q _4146_/X VGND VGND VPWR VPWR _4147_/X
+ sky130_fd_sc_hd__a221o_2
XFILLER_110_592 VGND VGND VPWR VPWR sky130_fd_sc_hd__decap_3
XFILLER_18_59 VGND VGND VPWR VPWR sky130_fd_sc_hd__decap_3
XFILLER_56_657 VGND VGND VPWR VPWR sky130_fd_sc_hd__decap_3
XFILLER_68_495 VGND VGND VPWR VPWR sky130_fd_sc_hd__decap_3
XFILLER_95_281 VGND VGND VPWR VPWR sky130_fd_sc_hd__decap_3
XFILLER_55_167 VGND VGND VPWR VPWR sky130_fd_sc_hd__fill_1
X_4078_ _7025_/Q _4437_/A2 _4435_/B1 _7371_/Q VGND VGND VPWR VPWR _4078_/X sky130_fd_sc_hd__a22o_2
XFILLER_43_329 VGND VGND VPWR VPWR sky130_fd_sc_hd__decap_3
XFILLER_55_178 VGND VGND VPWR VPWR sky130_fd_sc_hd__fill_2
XFILLER_55_189 VGND VGND VPWR VPWR sky130_fd_sc_hd__decap_3
XFILLER_64_690 VGND VGND VPWR VPWR sky130_fd_sc_hd__fill_2
XFILLER_71_638 VGND VGND VPWR VPWR sky130_fd_sc_hd__decap_3
XFILLER_34_14 VGND VGND VPWR VPWR sky130_fd_sc_hd__fill_1
XFILLER_51_340 VGND VGND VPWR VPWR sky130_fd_sc_hd__decap_3
XFILLER_70_137 VGND VGND VPWR VPWR sky130_fd_sc_hd__decap_3
XFILLER_24_587 VGND VGND VPWR VPWR sky130_fd_sc_hd__fill_1
XFILLER_51_362 VGND VGND VPWR VPWR sky130_fd_sc_hd__decap_3
XFILLER_11_237 VGND VGND VPWR VPWR sky130_fd_sc_hd__decap_3
Xclkload2 clkload2/A VGND VGND VPWR VPWR clkload2/X sky130_fd_sc_hd__clkbuf_16
X_6719_ _6966_/CLK _6719_/D VGND VGND VPWR VPWR _6719_/Q sky130_fd_sc_hd__dfxtp_2
XFILLER_50_35 VGND VGND VPWR VPWR sky130_fd_sc_hd__fill_2
XFILLER_109_169 VGND VGND VPWR VPWR sky130_fd_sc_hd__decap_3
XFILLER_50_68 VGND VGND VPWR VPWR sky130_fd_sc_hd__decap_3
XFILLER_50_79 VGND VGND VPWR VPWR sky130_fd_sc_hd__decap_3
XFILLER_3_414 VGND VGND VPWR VPWR sky130_fd_sc_hd__decap_3
XFILLER_3_447 VGND VGND VPWR VPWR sky130_fd_sc_hd__fill_1
XFILLER_115_50 VGND VGND VPWR VPWR sky130_fd_sc_hd__decap_3
XFILLER_115_72 VGND VGND VPWR VPWR sky130_fd_sc_hd__decap_3
XFILLER_19_304 VGND VGND VPWR VPWR sky130_fd_sc_hd__decap_3
XFILLER_93_207 VGND VGND VPWR VPWR sky130_fd_sc_hd__decap_3
XFILLER_19_337 VGND VGND VPWR VPWR sky130_fd_sc_hd__decap_3
XFILLER_47_635 VGND VGND VPWR VPWR sky130_fd_sc_hd__decap_3
XFILLER_74_421 VGND VGND VPWR VPWR sky130_fd_sc_hd__fill_1
XFILLER_74_432 VGND VGND VPWR VPWR sky130_fd_sc_hd__decap_3
XFILLER_75_43 VGND VGND VPWR VPWR sky130_fd_sc_hd__decap_3
XTAP_TAPCELL_ROW_70_1094 VGND VPWR sky130_fd_sc_hd__tapvpwrvgnd_1
XFILLER_46_134 VGND VGND VPWR VPWR sky130_fd_sc_hd__fill_2
XFILLER_47_668 VGND VGND VPWR VPWR sky130_fd_sc_hd__decap_3
XFILLER_47_679 VGND VGND VPWR VPWR sky130_fd_sc_hd__decap_3
XFILLER_74_454 VGND VGND VPWR VPWR sky130_fd_sc_hd__decap_3
XFILLER_75_87 VGND VGND VPWR VPWR sky130_fd_sc_hd__decap_3
XTAP_TAPCELL_ROW_109_1558 VGND VPWR sky130_fd_sc_hd__tapvpwrvgnd_1
XFILLER_46_189 VGND VGND VPWR VPWR sky130_fd_sc_hd__decap_3
XFILLER_61_126 VGND VGND VPWR VPWR sky130_fd_sc_hd__decap_3
XFILLER_62_638 VGND VGND VPWR VPWR sky130_fd_sc_hd__decap_3
XFILLER_15_532 VGND VGND VPWR VPWR sky130_fd_sc_hd__decap_3
XFILLER_61_159 VGND VGND VPWR VPWR sky130_fd_sc_hd__decap_3
XFILLER_15_587 VGND VGND VPWR VPWR sky130_fd_sc_hd__decap_3
XFILLER_42_362 VGND VGND VPWR VPWR sky130_fd_sc_hd__fill_2
XFILLER_70_682 VGND VGND VPWR VPWR sky130_fd_sc_hd__decap_3
XFILLER_98_9 VGND VGND VPWR VPWR sky130_fd_sc_hd__decap_3
XFILLER_42_384 VGND VGND VPWR VPWR sky130_fd_sc_hd__decap_3
XFILLER_91_97 VGND VGND VPWR VPWR sky130_fd_sc_hd__decap_3
XTAP_TAPCELL_ROW_53_891 VGND VPWR sky130_fd_sc_hd__tapvpwrvgnd_1
XFILLER_116_629 VGND VGND VPWR VPWR sky130_fd_sc_hd__fill_1
XFILLER_6_241 VGND VGND VPWR VPWR sky130_fd_sc_hd__fill_2
Xhold709 _6951_/Q VGND VGND VPWR VPWR _6951_/D sky130_fd_sc_hd__dlygate4sd3_1
XFILLER_115_128 VGND VGND VPWR VPWR sky130_fd_sc_hd__decap_3
X_3380_ _3528_/A _5118_/D VGND VGND VPWR VPWR _3380_/Y sky130_fd_sc_hd__nor2_2
XFILLER_69_237 VGND VGND VPWR VPWR sky130_fd_sc_hd__decap_3
X_5050_ _5086_/A _5101_/B _5100_/B _4366_/X VGND VGND VPWR VPWR _5050_/X sky130_fd_sc_hd__a31o_2
XFILLER_111_367 VGND VGND VPWR VPWR sky130_fd_sc_hd__decap_3
XFILLER_27_3 VGND VGND VPWR VPWR sky130_fd_sc_hd__decap_3
XFILLER_84_218 VGND VGND VPWR VPWR sky130_fd_sc_hd__decap_3
XFILLER_37_123 VGND VGND VPWR VPWR sky130_fd_sc_hd__decap_3
XFILLER_38_624 VGND VGND VPWR VPWR sky130_fd_sc_hd__decap_3
XFILLER_77_281 VGND VGND VPWR VPWR sky130_fd_sc_hd__fill_2
XTAP_TAPCELL_ROW_88_1311 VGND VPWR sky130_fd_sc_hd__tapvpwrvgnd_1
XFILLER_38_668 VGND VGND VPWR VPWR sky130_fd_sc_hd__decap_3
XFILLER_111_19 VGND VGND VPWR VPWR sky130_fd_sc_hd__decap_3
XFILLER_1_84 VGND VGND VPWR VPWR sky130_fd_sc_hd__decap_3
XFILLER_37_167 VGND VGND VPWR VPWR sky130_fd_sc_hd__fill_1
XFILLER_37_178 VGND VGND VPWR VPWR sky130_fd_sc_hd__decap_3
XFILLER_53_638 VGND VGND VPWR VPWR sky130_fd_sc_hd__decap_3
XFILLER_65_487 VGND VGND VPWR VPWR sky130_fd_sc_hd__decap_3
XFILLER_80_413 VGND VGND VPWR VPWR sky130_fd_sc_hd__decap_3
XFILLER_92_262 VGND VGND VPWR VPWR sky130_fd_sc_hd__decap_3
XFILLER_18_392 VGND VGND VPWR VPWR sky130_fd_sc_hd__fill_1
XFILLER_46_690 VGND VGND VPWR VPWR sky130_fd_sc_hd__fill_2
XFILLER_52_159 VGND VGND VPWR VPWR sky130_fd_sc_hd__decap_3
XFILLER_80_435 VGND VGND VPWR VPWR sky130_fd_sc_hd__decap_3
X_4903_ _4903_/A _4903_/B _4903_/C VGND VGND VPWR VPWR _4903_/X sky130_fd_sc_hd__and3_2
XFILLER_21_513 VGND VGND VPWR VPWR sky130_fd_sc_hd__decap_3
XFILLER_33_362 VGND VGND VPWR VPWR sky130_fd_sc_hd__decap_3
XFILLER_61_671 VGND VGND VPWR VPWR sky130_fd_sc_hd__fill_1
XFILLER_61_682 VGND VGND VPWR VPWR sky130_fd_sc_hd__decap_3
XFILLER_21_535 VGND VGND VPWR VPWR sky130_fd_sc_hd__decap_3
XFILLER_33_384 VGND VGND VPWR VPWR sky130_fd_sc_hd__decap_3
X_4834_ _4834_/A _4834_/B VGND VGND VPWR VPWR _4834_/Y sky130_fd_sc_hd__nor2_2
X_4765_ _4788_/A _4765_/B VGND VGND VPWR VPWR _4766_/A sky130_fd_sc_hd__and2_2
X_6504_ _6570_/A VGND VGND VPWR VPWR _6504_/Y sky130_fd_sc_hd__inv_2
XTAP_TAPCELL_ROW_99_1440 VGND VPWR sky130_fd_sc_hd__tapvpwrvgnd_1
XFILLER_107_607 VGND VGND VPWR VPWR sky130_fd_sc_hd__decap_3
X_4696_ _5118_/C _4696_/B VGND VGND VPWR VPWR _5670_/B sky130_fd_sc_hd__nor2_2
XFILLER_106_106 VGND VGND VPWR VPWR sky130_fd_sc_hd__decap_3
XFILLER_20_38 VGND VGND VPWR VPWR sky130_fd_sc_hd__decap_3
X_6435_ _6599_/A VGND VGND VPWR VPWR _6435_/Y sky130_fd_sc_hd__inv_2
XFILLER_115_662 VGND VGND VPWR VPWR sky130_fd_sc_hd__decap_3
X_6366_ _6366_/A VGND VGND VPWR VPWR _6366_/Y sky130_fd_sc_hd__inv_2
X_3578_ _7284_/Q _5136_/S _3417_/X _7092_/Q VGND VGND VPWR VPWR _3583_/A sky130_fd_sc_hd__a22o_2
XFILLER_114_150 VGND VGND VPWR VPWR sky130_fd_sc_hd__decap_3
XFILLER_115_673 VGND VGND VPWR VPWR sky130_fd_sc_hd__decap_3
XFILLER_88_513 VGND VGND VPWR VPWR sky130_fd_sc_hd__fill_1
X_5317_ _5317_/A0 _4899_/X _5327_/S VGND VGND VPWR VPWR _7172_/D sky130_fd_sc_hd__mux2_2
XFILLER_102_323 VGND VGND VPWR VPWR sky130_fd_sc_hd__decap_3
XFILLER_114_183 VGND VGND VPWR VPWR sky130_fd_sc_hd__decap_3
X_6297_ _6548_/A VGND VGND VPWR VPWR _6297_/Y sky130_fd_sc_hd__inv_2
XFILLER_29_36 VGND VGND VPWR VPWR sky130_fd_sc_hd__decap_3
XFILLER_29_69 VGND VGND VPWR VPWR sky130_fd_sc_hd__decap_3
XFILLER_75_218 VGND VGND VPWR VPWR sky130_fd_sc_hd__decap_3
XFILLER_102_389 VGND VGND VPWR VPWR sky130_fd_sc_hd__decap_3
XFILLER_28_112 VGND VGND VPWR VPWR sky130_fd_sc_hd__decap_3
XFILLER_56_421 VGND VGND VPWR VPWR sky130_fd_sc_hd__decap_3
XFILLER_68_270 VGND VGND VPWR VPWR sky130_fd_sc_hd__decap_3
X_5179_ _5179_/A _5182_/B VGND VGND VPWR VPWR _7238_/D sky130_fd_sc_hd__and2_2
XFILLER_28_156 VGND VGND VPWR VPWR sky130_fd_sc_hd__decap_3
XFILLER_16_307 VGND VGND VPWR VPWR sky130_fd_sc_hd__fill_1
XFILLER_16_318 VGND VGND VPWR VPWR sky130_fd_sc_hd__decap_3
XFILLER_28_189 VGND VGND VPWR VPWR sky130_fd_sc_hd__decap_3
XFILLER_44_627 VGND VGND VPWR VPWR sky130_fd_sc_hd__decap_3
XFILLER_45_24 VGND VGND VPWR VPWR sky130_fd_sc_hd__decap_3
XFILLER_71_402 VGND VGND VPWR VPWR sky130_fd_sc_hd__fill_1
XFILLER_83_262 VGND VGND VPWR VPWR sky130_fd_sc_hd__decap_3
XTAP_TAPCELL_ROW_3_288 VGND VPWR sky130_fd_sc_hd__tapvpwrvgnd_1
XFILLER_37_690 VGND VGND VPWR VPWR sky130_fd_sc_hd__fill_2
XFILLER_45_68 VGND VGND VPWR VPWR sky130_fd_sc_hd__fill_2
XFILLER_24_340 VGND VGND VPWR VPWR sky130_fd_sc_hd__decap_3
XFILLER_24_362 VGND VGND VPWR VPWR sky130_fd_sc_hd__fill_2
XFILLER_52_660 VGND VGND VPWR VPWR sky130_fd_sc_hd__decap_3
XFILLER_51_181 VGND VGND VPWR VPWR sky130_fd_sc_hd__fill_2
XFILLER_61_34 VGND VGND VPWR VPWR sky130_fd_sc_hd__decap_3
XTAP_TAPCELL_ROW_104_1499 VGND VPWR sky130_fd_sc_hd__tapvpwrvgnd_1
XTAP_TAPCELL_ROW_50_850 VGND VPWR sky130_fd_sc_hd__tapvpwrvgnd_1
XFILLER_61_78 VGND VGND VPWR VPWR sky130_fd_sc_hd__decap_3
XFILLER_6_18 VGND VGND VPWR VPWR sky130_fd_sc_hd__decap_3
XFILLER_6_29 VGND VGND VPWR VPWR sky130_fd_sc_hd__decap_3
XFILLER_3_200 VGND VGND VPWR VPWR sky130_fd_sc_hd__decap_3
XFILLER_106_640 VGND VGND VPWR VPWR sky130_fd_sc_hd__decap_3
XFILLER_106_651 VGND VGND VPWR VPWR sky130_fd_sc_hd__decap_3
XFILLER_105_150 VGND VGND VPWR VPWR sky130_fd_sc_hd__decap_3
XFILLER_106_684 VGND VGND VPWR VPWR sky130_fd_sc_hd__decap_3
XFILLER_10_71 VGND VGND VPWR VPWR sky130_fd_sc_hd__decap_3
XFILLER_112_109 VGND VGND VPWR VPWR sky130_fd_sc_hd__decap_3
XFILLER_3_255 VGND VGND VPWR VPWR sky130_fd_sc_hd__decap_3
XFILLER_79_502 VGND VGND VPWR VPWR sky130_fd_sc_hd__fill_2
XTAP_TAPCELL_ROW_72_1112 VGND VPWR sky130_fd_sc_hd__tapvpwrvgnd_1
XFILLER_86_64 VGND VGND VPWR VPWR sky130_fd_sc_hd__decap_3
XFILLER_59_270 VGND VGND VPWR VPWR sky130_fd_sc_hd__decap_3
XFILLER_59_281 VGND VGND VPWR VPWR sky130_fd_sc_hd__decap_3
XFILLER_66_229 VGND VGND VPWR VPWR sky130_fd_sc_hd__decap_3
XFILLER_86_97 VGND VGND VPWR VPWR sky130_fd_sc_hd__decap_3
XFILLER_19_156 VGND VGND VPWR VPWR sky130_fd_sc_hd__decap_3
XTAP_TAPCELL_ROW_58_950 VGND VPWR sky130_fd_sc_hd__tapvpwrvgnd_1
XFILLER_19_178 VGND VGND VPWR VPWR sky130_fd_sc_hd__decap_3
XFILLER_62_424 VGND VGND VPWR VPWR sky130_fd_sc_hd__decap_3
XFILLER_28_690 VGND VGND VPWR VPWR sky130_fd_sc_hd__fill_2
XFILLER_34_126 VGND VGND VPWR VPWR sky130_fd_sc_hd__fill_1
XFILLER_34_159 VGND VGND VPWR VPWR sky130_fd_sc_hd__decap_3
XFILLER_43_671 VGND VGND VPWR VPWR sky130_fd_sc_hd__fill_1
XTAP_TAPCELL_ROW_83_1252 VGND VPWR sky130_fd_sc_hd__tapvpwrvgnd_1
XFILLER_43_682 VGND VGND VPWR VPWR sky130_fd_sc_hd__decap_3
XFILLER_30_332 VGND VGND VPWR VPWR sky130_fd_sc_hd__fill_2
XFILLER_30_376 VGND VGND VPWR VPWR sky130_fd_sc_hd__fill_2
XFILLER_7_550 VGND VGND VPWR VPWR sky130_fd_sc_hd__fill_1
X_4550_ _4550_/A _4567_/B VGND VGND VPWR VPWR _7305_/D sky130_fd_sc_hd__and2_2
XFILLER_116_437 VGND VGND VPWR VPWR sky130_fd_sc_hd__fill_1
XFILLER_7_561 VGND VGND VPWR VPWR sky130_fd_sc_hd__fill_2
X_3501_ _5144_/A _5144_/B _3500_/Y VGND VGND VPWR VPWR _3501_/X sky130_fd_sc_hd__a21o_2
XFILLER_112_610 VGND VGND VPWR VPWR sky130_fd_sc_hd__decap_3
X_3363_ _6982_/Q _5670_/A _3362_/A VGND VGND VPWR VPWR _5294_/B sky130_fd_sc_hd__or3b_4
XTAP_TAPCELL_ROW_94_1381 VGND VPWR sky130_fd_sc_hd__tapvpwrvgnd_1
XFILLER_112_643 VGND VGND VPWR VPWR sky130_fd_sc_hd__fill_1
XFILLER_112_654 VGND VGND VPWR VPWR sky130_fd_sc_hd__decap_3
X_5102_ _5114_/A _4343_/X _5100_/Y _3618_/X _5101_/Y VGND VGND VPWR VPWR _5102_/X
+ sky130_fd_sc_hd__a221o_2
XFILLER_111_131 VGND VGND VPWR VPWR sky130_fd_sc_hd__decap_3
XFILLER_112_687 VGND VGND VPWR VPWR sky130_fd_sc_hd__decap_3
XFILLER_57_207 VGND VGND VPWR VPWR sky130_fd_sc_hd__decap_3
XFILLER_97_354 VGND VGND VPWR VPWR sky130_fd_sc_hd__decap_3
XFILLER_97_376 VGND VGND VPWR VPWR sky130_fd_sc_hd__decap_3
Xhold1206 _7150_/Q VGND VGND VPWR VPWR _5365_/A0 sky130_fd_sc_hd__dlygate4sd3_1
XFILLER_111_175 VGND VGND VPWR VPWR sky130_fd_sc_hd__decap_3
XFILLER_111_197 VGND VGND VPWR VPWR sky130_fd_sc_hd__decap_3
Xhold1217 _7325_/Q VGND VGND VPWR VPWR _3966_/A1 sky130_fd_sc_hd__dlygate4sd3_1
X_5033_ _5114_/A _4629_/Y _5032_/A _5033_/B2 VGND VGND VPWR VPWR _5033_/X sky130_fd_sc_hd__a22o_2
XFILLER_53_402 VGND VGND VPWR VPWR sky130_fd_sc_hd__decap_3
XFILLER_65_284 VGND VGND VPWR VPWR sky130_fd_sc_hd__decap_3
XTAP_TAPCELL_ROW_0_236 VGND VPWR sky130_fd_sc_hd__tapvpwrvgnd_1
XFILLER_25_126 VGND VGND VPWR VPWR sky130_fd_sc_hd__fill_1
XFILLER_25_137 VGND VGND VPWR VPWR sky130_fd_sc_hd__decap_3
XFILLER_53_435 VGND VGND VPWR VPWR sky130_fd_sc_hd__fill_2
X_6984_ _7264_/CLK _6984_/D _6264_/Y VGND VGND VPWR VPWR _6984_/Q sky130_fd_sc_hd__dfrtp_2
XTAP_TAPCELL_ROW_0_247 VGND VPWR sky130_fd_sc_hd__tapvpwrvgnd_1
XFILLER_15_27 VGND VGND VPWR VPWR sky130_fd_sc_hd__decap_3
XFILLER_33_181 VGND VGND VPWR VPWR sky130_fd_sc_hd__decap_3
XFILLER_40_129 VGND VGND VPWR VPWR sky130_fd_sc_hd__decap_3
XTAP_TAPCELL_ROW_36_688 VGND VPWR sky130_fd_sc_hd__tapvpwrvgnd_1
X_4817_ _4810_/X _4811_/X _4815_/X _4816_/X VGND VGND VPWR VPWR _5663_/B sky130_fd_sc_hd__a211o_2
XFILLER_21_376 VGND VGND VPWR VPWR sky130_fd_sc_hd__fill_2
XFILLER_21_387 VGND VGND VPWR VPWR sky130_fd_sc_hd__decap_3
XFILLER_31_26 VGND VGND VPWR VPWR sky130_fd_sc_hd__decap_3
XFILLER_31_48 VGND VGND VPWR VPWR sky130_fd_sc_hd__decap_3
X_4748_ _3683_/Y _5664_/B _3509_/B VGND VGND VPWR VPWR _4751_/A sky130_fd_sc_hd__a21o_2
X_4679_ _6990_/Q _5014_/B VGND VGND VPWR VPWR _5015_/B sky130_fd_sc_hd__nand2_2
X_6418_ _6578_/A VGND VGND VPWR VPWR _6418_/Y sky130_fd_sc_hd__inv_2
XPHY_EDGE_ROW_1_Right_1 VGND VGND VPWR VPWR sky130_fd_sc_hd__decap_3
X_7398_ _7401_/CLK _7398_/D _6678_/Y VGND VGND VPWR VPWR _7398_/Q sky130_fd_sc_hd__dfrtp_2
XFILLER_0_225 VGND VGND VPWR VPWR sky130_fd_sc_hd__decap_3
XFILLER_88_321 VGND VGND VPWR VPWR sky130_fd_sc_hd__fill_2
X_6349_ _6540_/A VGND VGND VPWR VPWR _6349_/Y sky130_fd_sc_hd__inv_2
XTAP_TAPCELL_ROW_8_347 VGND VPWR sky130_fd_sc_hd__tapvpwrvgnd_1
XFILLER_103_654 VGND VGND VPWR VPWR sky130_fd_sc_hd__decap_3
XFILLER_103_676 VGND VGND VPWR VPWR sky130_fd_sc_hd__decap_3
XFILLER_88_365 VGND VGND VPWR VPWR sky130_fd_sc_hd__decap_3
XFILLER_102_197 VGND VGND VPWR VPWR sky130_fd_sc_hd__fill_2
XFILLER_56_12 VGND VGND VPWR VPWR sky130_fd_sc_hd__decap_3
XFILLER_88_387 VGND VGND VPWR VPWR sky130_fd_sc_hd__decap_3
XFILLER_29_443 VGND VGND VPWR VPWR sky130_fd_sc_hd__decap_3
XFILLER_56_262 VGND VGND VPWR VPWR sky130_fd_sc_hd__decap_3
XFILLER_16_115 VGND VGND VPWR VPWR sky130_fd_sc_hd__decap_3
XFILLER_56_295 VGND VGND VPWR VPWR sky130_fd_sc_hd__decap_3
XTAP_TAPCELL_ROW_106_1528 VGND VPWR sky130_fd_sc_hd__tapvpwrvgnd_1
XFILLER_112_62 VGND VGND VPWR VPWR sky130_fd_sc_hd__decap_3
XFILLER_16_159 VGND VGND VPWR VPWR sky130_fd_sc_hd__decap_3
XFILLER_71_265 VGND VGND VPWR VPWR sky130_fd_sc_hd__decap_3
XFILLER_12_321 VGND VGND VPWR VPWR sky130_fd_sc_hd__decap_3
XFILLER_24_170 VGND VGND VPWR VPWR sky130_fd_sc_hd__decap_3
XFILLER_71_287 VGND VGND VPWR VPWR sky130_fd_sc_hd__decap_3
XFILLER_72_66 VGND VGND VPWR VPWR sky130_fd_sc_hd__decap_3
XFILLER_12_354 VGND VGND VPWR VPWR sky130_fd_sc_hd__decap_3
XFILLER_72_99 VGND VGND VPWR VPWR sky130_fd_sc_hd__decap_3
XFILLER_12_365 VGND VGND VPWR VPWR sky130_fd_sc_hd__decap_3
XFILLER_40_674 VGND VGND VPWR VPWR sky130_fd_sc_hd__decap_3
XFILLER_113_407 VGND VGND VPWR VPWR sky130_fd_sc_hd__decap_3
XFILLER_97_30 VGND VGND VPWR VPWR sky130_fd_sc_hd__decap_3
XFILLER_98_129 VGND VGND VPWR VPWR sky130_fd_sc_hd__decap_3
XFILLER_79_343 VGND VGND VPWR VPWR sky130_fd_sc_hd__decap_3
XFILLER_97_52 VGND VGND VPWR VPWR sky130_fd_sc_hd__decap_3
XFILLER_67_505 VGND VGND VPWR VPWR sky130_fd_sc_hd__fill_1
XFILLER_79_365 VGND VGND VPWR VPWR sky130_fd_sc_hd__decap_3
XFILLER_94_302 VGND VGND VPWR VPWR sky130_fd_sc_hd__decap_3
XFILLER_39_218 VGND VGND VPWR VPWR sky130_fd_sc_hd__decap_3
XFILLER_11_6 VGND VGND VPWR VPWR sky130_fd_sc_hd__decap_3
XFILLER_35_402 VGND VGND VPWR VPWR sky130_fd_sc_hd__decap_3
XFILLER_94_379 VGND VGND VPWR VPWR sky130_fd_sc_hd__decap_3
XFILLER_47_295 VGND VGND VPWR VPWR sky130_fd_sc_hd__decap_3
XFILLER_62_221 VGND VGND VPWR VPWR sky130_fd_sc_hd__decap_3
XFILLER_50_405 VGND VGND VPWR VPWR sky130_fd_sc_hd__decap_3
XFILLER_62_243 VGND VGND VPWR VPWR sky130_fd_sc_hd__decap_3
X_3981_ _7350_/Q _7318_/Q _3989_/S VGND VGND VPWR VPWR _7350_/D sky130_fd_sc_hd__mux2_2
XFILLER_22_118 VGND VGND VPWR VPWR sky130_fd_sc_hd__fill_2
XFILLER_62_276 VGND VGND VPWR VPWR sky130_fd_sc_hd__decap_3
XFILLER_15_181 VGND VGND VPWR VPWR sky130_fd_sc_hd__decap_3
XFILLER_31_641 VGND VGND VPWR VPWR sky130_fd_sc_hd__decap_3
XFILLER_94_3 VGND VGND VPWR VPWR sky130_fd_sc_hd__decap_3
Xclkbuf_leaf_42_clk clkbuf_3_0__f_clk/X VGND VGND VPWR VPWR clkload7/A sky130_fd_sc_hd__clkbuf_16
XTAP_TAPCELL_ROW_61_978 VGND VPWR sky130_fd_sc_hd__tapvpwrvgnd_1
XTAP_TAPCELL_ROW_33_647 VGND VPWR sky130_fd_sc_hd__tapvpwrvgnd_1
XFILLER_30_173 VGND VGND VPWR VPWR sky130_fd_sc_hd__decap_3
X_5651_ _5651_/A VGND VGND VPWR VPWR _5651_/Y sky130_fd_sc_hd__inv_2
XTAP_TAPCELL_ROW_61_989 VGND VPWR sky130_fd_sc_hd__tapvpwrvgnd_1
XFILLER_116_212 VGND VGND VPWR VPWR sky130_fd_sc_hd__fill_2
XFILLER_7_72 VGND VGND VPWR VPWR sky130_fd_sc_hd__decap_3
X_7321_ _7356_/CLK _7321_/D _6601_/Y VGND VGND VPWR VPWR _7321_/Q sky130_fd_sc_hd__dfrtp_2
XFILLER_116_234 VGND VGND VPWR VPWR sky130_fd_sc_hd__decap_3
X_7252_ clkload8/A _7252_/D _6532_/Y VGND VGND VPWR VPWR _7252_/Q sky130_fd_sc_hd__dfrtp_2
XFILLER_116_267 VGND VGND VPWR VPWR sky130_fd_sc_hd__decap_3
XFILLER_116_289 VGND VGND VPWR VPWR sky130_fd_sc_hd__decap_3
X_4464_ _3541_/X _3610_/B _4463_/X VGND VGND VPWR VPWR _5655_/C sky130_fd_sc_hd__o21ai_2
X_7183_ _7387_/CLK _7183_/D _6463_/Y VGND VGND VPWR VPWR _7183_/Q sky130_fd_sc_hd__dfrtp_2
X_4395_ _4396_/A _4444_/B VGND VGND VPWR VPWR _4397_/A sky130_fd_sc_hd__and2_2
X_3415_ _3449_/B _3449_/C _3417_/C VGND VGND VPWR VPWR _5136_/S sky130_fd_sc_hd__and3_4
XFILLER_98_641 VGND VGND VPWR VPWR sky130_fd_sc_hd__decap_3
XFILLER_112_451 VGND VGND VPWR VPWR sky130_fd_sc_hd__decap_3
XFILLER_58_505 VGND VGND VPWR VPWR sky130_fd_sc_hd__fill_1
X_3346_ _3346_/A VGND VGND VPWR VPWR _3509_/B sky130_fd_sc_hd__inv_2
XTAP_TAPCELL_ROW_5_317 VGND VPWR sky130_fd_sc_hd__tapvpwrvgnd_1
XTAP_TAPCELL_ROW_5_306 VGND VPWR sky130_fd_sc_hd__tapvpwrvgnd_1
XFILLER_98_663 VGND VGND VPWR VPWR sky130_fd_sc_hd__decap_3
XFILLER_100_635 VGND VGND VPWR VPWR sky130_fd_sc_hd__fill_1
XFILLER_112_473 VGND VGND VPWR VPWR sky130_fd_sc_hd__decap_3
XFILLER_85_324 VGND VGND VPWR VPWR sky130_fd_sc_hd__decap_3
Xhold1003 _7202_/Q VGND VGND VPWR VPWR _5256_/A0 sky130_fd_sc_hd__dlygate4sd3_1
Xhold1014 _7204_/Q VGND VGND VPWR VPWR _5251_/A0 sky130_fd_sc_hd__dlygate4sd3_1
XFILLER_100_657 VGND VGND VPWR VPWR sky130_fd_sc_hd__decap_3
XFILLER_85_346 VGND VGND VPWR VPWR sky130_fd_sc_hd__decap_3
Xhold1025 _7225_/Q VGND VGND VPWR VPWR _5207_/A sky130_fd_sc_hd__dlygate4sd3_1
Xhold1036 _7276_/Q VGND VGND VPWR VPWR _4753_/A0 sky130_fd_sc_hd__dlygate4sd3_1
Xhold1047 _7268_/Q VGND VGND VPWR VPWR _4901_/A0 sky130_fd_sc_hd__dlygate4sd3_1
Xhold1058 _7012_/Q VGND VGND VPWR VPWR _5632_/A sky130_fd_sc_hd__dlygate4sd3_1
X_5016_ _5032_/A _5031_/B _4629_/Y VGND VGND VPWR VPWR _5017_/B sky130_fd_sc_hd__a21oi_2
XFILLER_26_15 VGND VGND VPWR VPWR sky130_fd_sc_hd__decap_3
XFILLER_26_413 VGND VGND VPWR VPWR sky130_fd_sc_hd__decap_3
XFILLER_38_240 VGND VGND VPWR VPWR sky130_fd_sc_hd__decap_3
XFILLER_38_262 VGND VGND VPWR VPWR sky130_fd_sc_hd__decap_3
Xhold1069 _7388_/Q VGND VGND VPWR VPWR _3833_/A0 sky130_fd_sc_hd__dlygate4sd3_1
XFILLER_26_424 VGND VGND VPWR VPWR sky130_fd_sc_hd__decap_3
XFILLER_38_295 VGND VGND VPWR VPWR sky130_fd_sc_hd__decap_3
XFILLER_53_243 VGND VGND VPWR VPWR sky130_fd_sc_hd__decap_3
X_6967_ _6972_/CLK _6967_/D VGND VGND VPWR VPWR _6967_/Q sky130_fd_sc_hd__dfxtp_2
XFILLER_41_438 VGND VGND VPWR VPWR sky130_fd_sc_hd__decap_3
XFILLER_41_449 VGND VGND VPWR VPWR sky130_fd_sc_hd__fill_1
XFILLER_53_276 VGND VGND VPWR VPWR sky130_fd_sc_hd__decap_3
XFILLER_53_287 VGND VGND VPWR VPWR sky130_fd_sc_hd__fill_1
XFILLER_81_596 VGND VGND VPWR VPWR sky130_fd_sc_hd__decap_3
XFILLER_22_630 VGND VGND VPWR VPWR sky130_fd_sc_hd__fill_1
Xclkbuf_leaf_33_clk clkbuf_3_0__f_clk/X VGND VGND VPWR VPWR _6975_/CLK sky130_fd_sc_hd__clkbuf_16
X_6898_ _6911_/CLK _6898_/D VGND VGND VPWR VPWR _6898_/Q sky130_fd_sc_hd__dfxtp_2
XFILLER_21_140 VGND VGND VPWR VPWR sky130_fd_sc_hd__decap_3
XFILLER_22_674 VGND VGND VPWR VPWR sky130_fd_sc_hd__fill_1
XTAP_TAPCELL_ROW_101_1469 VGND VPWR sky130_fd_sc_hd__tapvpwrvgnd_1
XTAP_TAPCELL_ROW_101_1458 VGND VPWR sky130_fd_sc_hd__tapvpwrvgnd_1
XFILLER_21_184 VGND VGND VPWR VPWR sky130_fd_sc_hd__decap_3
XFILLER_5_317 VGND VGND VPWR VPWR sky130_fd_sc_hd__decap_3
XFILLER_107_234 VGND VGND VPWR VPWR sky130_fd_sc_hd__decap_3
XFILLER_89_641 VGND VGND VPWR VPWR sky130_fd_sc_hd__decap_3
Xhold870 _7101_/Q VGND VGND VPWR VPWR _7101_/D sky130_fd_sc_hd__dlygate4sd3_1
Xhold881 _7081_/Q VGND VGND VPWR VPWR _7081_/D sky130_fd_sc_hd__dlygate4sd3_1
XFILLER_103_440 VGND VGND VPWR VPWR sky130_fd_sc_hd__decap_3
XFILLER_107_84 VGND VGND VPWR VPWR sky130_fd_sc_hd__decap_3
XFILLER_1_556 VGND VGND VPWR VPWR sky130_fd_sc_hd__decap_3
XFILLER_49_505 VGND VGND VPWR VPWR sky130_fd_sc_hd__fill_1
XFILLER_89_663 VGND VGND VPWR VPWR sky130_fd_sc_hd__decap_3
Xhold892 _7079_/Q VGND VGND VPWR VPWR _7079_/D sky130_fd_sc_hd__dlygate4sd3_1
XFILLER_67_33 VGND VGND VPWR VPWR sky130_fd_sc_hd__decap_3
XFILLER_76_324 VGND VGND VPWR VPWR sky130_fd_sc_hd__decap_3
XFILLER_88_162 VGND VGND VPWR VPWR sky130_fd_sc_hd__decap_3
XFILLER_89_685 VGND VGND VPWR VPWR sky130_fd_sc_hd__decap_3
XTAP_TAPCELL_ROW_112_1598 VGND VPWR sky130_fd_sc_hd__tapvpwrvgnd_1
XFILLER_76_357 VGND VGND VPWR VPWR sky130_fd_sc_hd__fill_1
XFILLER_88_195 VGND VGND VPWR VPWR sky130_fd_sc_hd__fill_1
XFILLER_17_402 VGND VGND VPWR VPWR sky130_fd_sc_hd__fill_2
XFILLER_29_251 VGND VGND VPWR VPWR sky130_fd_sc_hd__decap_3
XFILLER_29_273 VGND VGND VPWR VPWR sky130_fd_sc_hd__decap_3
XFILLER_76_379 VGND VGND VPWR VPWR sky130_fd_sc_hd__fill_1
XFILLER_91_327 VGND VGND VPWR VPWR sky130_fd_sc_hd__decap_3
XFILLER_29_284 VGND VGND VPWR VPWR sky130_fd_sc_hd__decap_3
XFILLER_91_349 VGND VGND VPWR VPWR sky130_fd_sc_hd__fill_1
XFILLER_72_552 VGND VGND VPWR VPWR sky130_fd_sc_hd__decap_3
XFILLER_83_54 VGND VGND VPWR VPWR sky130_fd_sc_hd__fill_2
XTAP_TAPCELL_ROW_67_1055 VGND VPWR sky130_fd_sc_hd__tapvpwrvgnd_1
XFILLER_32_438 VGND VGND VPWR VPWR sky130_fd_sc_hd__decap_3
XFILLER_44_287 VGND VGND VPWR VPWR sky130_fd_sc_hd__decap_3
XFILLER_83_98 VGND VGND VPWR VPWR sky130_fd_sc_hd__decap_3
XTAP_TAPCELL_ROW_80_1211 VGND VPWR sky130_fd_sc_hd__tapvpwrvgnd_1
Xclkbuf_leaf_24_clk clkload1/A VGND VGND VPWR VPWR _6959_/CLK sky130_fd_sc_hd__clkbuf_16
XFILLER_13_685 VGND VGND VPWR VPWR sky130_fd_sc_hd__decap_3
XFILLER_8_100 VGND VGND VPWR VPWR sky130_fd_sc_hd__decap_3
XTAP_TAPCELL_ROW_30_617 VGND VPWR sky130_fd_sc_hd__tapvpwrvgnd_1
XTAP_TAPCELL_ROW_30_606 VGND VPWR sky130_fd_sc_hd__tapvpwrvgnd_1
XFILLER_9_612 VGND VGND VPWR VPWR sky130_fd_sc_hd__decap_3
XFILLER_12_195 VGND VGND VPWR VPWR sky130_fd_sc_hd__fill_1
XFILLER_8_144 VGND VGND VPWR VPWR sky130_fd_sc_hd__decap_3
XFILLER_9_667 VGND VGND VPWR VPWR sky130_fd_sc_hd__decap_3
XFILLER_32_80 VGND VGND VPWR VPWR sky130_fd_sc_hd__decap_3
XFILLER_32_91 VGND VGND VPWR VPWR sky130_fd_sc_hd__decap_3
XTAP_TAPCELL_ROW_10_374 VGND VPWR sky130_fd_sc_hd__tapvpwrvgnd_1
XFILLER_59_6 VGND VGND VPWR VPWR sky130_fd_sc_hd__decap_3
XTAP_TAPCELL_ROW_78_1184 VGND VPWR sky130_fd_sc_hd__tapvpwrvgnd_1
XFILLER_99_416 VGND VGND VPWR VPWR sky130_fd_sc_hd__decap_3
XFILLER_113_237 VGND VGND VPWR VPWR sky130_fd_sc_hd__decap_3
XTAP_TAPCELL_ROW_91_1340 VGND VPWR sky130_fd_sc_hd__tapvpwrvgnd_1
XFILLER_99_449 VGND VGND VPWR VPWR sky130_fd_sc_hd__fill_2
XFILLER_79_140 VGND VGND VPWR VPWR sky130_fd_sc_hd__decap_3
X_4180_ _7232_/Q _4469_/A3 _4503_/S _7045_/Q VGND VGND VPWR VPWR _4180_/X sky130_fd_sc_hd__a22o_2
XFILLER_79_184 VGND VGND VPWR VPWR sky130_fd_sc_hd__decap_3
XFILLER_95_611 VGND VGND VPWR VPWR sky130_fd_sc_hd__decap_3
XFILLER_67_357 VGND VGND VPWR VPWR sky130_fd_sc_hd__fill_1
XFILLER_94_121 VGND VGND VPWR VPWR sky130_fd_sc_hd__fill_1
XFILLER_67_379 VGND VGND VPWR VPWR sky130_fd_sc_hd__decap_3
XFILLER_82_305 VGND VGND VPWR VPWR sky130_fd_sc_hd__decap_3
XFILLER_82_327 VGND VGND VPWR VPWR sky130_fd_sc_hd__decap_3
XFILLER_94_176 VGND VGND VPWR VPWR sky130_fd_sc_hd__decap_3
XFILLER_95_688 VGND VGND VPWR VPWR sky130_fd_sc_hd__decap_3
XTAP_TAPCELL_ROW_38_706 VGND VPWR sky130_fd_sc_hd__tapvpwrvgnd_1
XFILLER_94_187 VGND VGND VPWR VPWR sky130_fd_sc_hd__fill_2
XFILLER_35_232 VGND VGND VPWR VPWR sky130_fd_sc_hd__decap_3
XFILLER_35_265 VGND VGND VPWR VPWR sky130_fd_sc_hd__decap_3
XFILLER_63_541 VGND VGND VPWR VPWR sky130_fd_sc_hd__fill_2
X_6821_ _6929_/CLK _6821_/D VGND VGND VPWR VPWR _6821_/Q sky130_fd_sc_hd__dfxtp_2
XFILLER_23_427 VGND VGND VPWR VPWR sky130_fd_sc_hd__decap_3
XFILLER_90_360 VGND VGND VPWR VPWR sky130_fd_sc_hd__decap_3
XTAP_TAPCELL_ROW_18_463 VGND VPWR sky130_fd_sc_hd__tapvpwrvgnd_1
Xclkbuf_leaf_15_clk clkload3/A VGND VGND VPWR VPWR _7374_/CLK sky130_fd_sc_hd__clkbuf_16
X_6752_ _6966_/CLK _6752_/D VGND VGND VPWR VPWR _6752_/Q sky130_fd_sc_hd__dfxtp_2
X_3964_ _7358_/Q _4507_/A0 _3968_/S VGND VGND VPWR VPWR _3964_/X sky130_fd_sc_hd__mux2_2
X_6683_ _6683_/A VGND VGND VPWR VPWR _6683_/Y sky130_fd_sc_hd__inv_2
X_5703_ _7357_/Q hold909/X _5719_/S VGND VGND VPWR VPWR _6701_/D sky130_fd_sc_hd__mux2_2
X_3895_ _3923_/A1 _3887_/X _3889_/X _3741_/X _3894_/X VGND VGND VPWR VPWR _3895_/X
+ sky130_fd_sc_hd__a221o_2
X_5634_ _5634_/A _5634_/B VGND VGND VPWR VPWR _7011_/D sky130_fd_sc_hd__and2_2
X_7304_ _7368_/CLK _7304_/D _6584_/Y VGND VGND VPWR VPWR _7304_/Q sky130_fd_sc_hd__dfrtp_2
XFILLER_2_309 VGND VGND VPWR VPWR sky130_fd_sc_hd__decap_3
XFILLER_104_215 VGND VGND VPWR VPWR sky130_fd_sc_hd__decap_3
XFILLER_104_226 VGND VGND VPWR VPWR sky130_fd_sc_hd__decap_3
X_7235_ _7363_/CLK _7235_/D _6515_/Y VGND VGND VPWR VPWR _7235_/Q sky130_fd_sc_hd__dfrtp_2
X_4447_ _4647_/C _4447_/B VGND VGND VPWR VPWR _4447_/Y sky130_fd_sc_hd__nor2_2
XFILLER_104_259 VGND VGND VPWR VPWR sky130_fd_sc_hd__decap_3
XFILLER_86_600 VGND VGND VPWR VPWR sky130_fd_sc_hd__decap_3
X_7166_ _7358_/CLK _7166_/D _6446_/Y VGND VGND VPWR VPWR _7166_/Q sky130_fd_sc_hd__dfrtp_2
XFILLER_112_270 VGND VGND VPWR VPWR sky130_fd_sc_hd__decap_3
XFILLER_58_302 VGND VGND VPWR VPWR sky130_fd_sc_hd__decap_3
XFILLER_58_324 VGND VGND VPWR VPWR sky130_fd_sc_hd__decap_3
XFILLER_85_110 VGND VGND VPWR VPWR sky130_fd_sc_hd__fill_2
X_4378_ _4243_/Y _4277_/Y _5032_/B _4377_/Y VGND VGND VPWR VPWR _4968_/A sky130_fd_sc_hd__a31o_4
XFILLER_100_421 VGND VGND VPWR VPWR sky130_fd_sc_hd__fill_2
XFILLER_85_143 VGND VGND VPWR VPWR sky130_fd_sc_hd__decap_3
X_7097_ clkload9/A _7097_/D _6377_/Y VGND VGND VPWR VPWR _7097_/Q sky130_fd_sc_hd__dfrtp_2
X_3329_ _3330_/A _3340_/C VGND VGND VPWR VPWR _3329_/Y sky130_fd_sc_hd__nand2_2
XFILLER_58_368 VGND VGND VPWR VPWR sky130_fd_sc_hd__fill_1
XFILLER_86_677 VGND VGND VPWR VPWR sky130_fd_sc_hd__decap_3
XFILLER_100_498 VGND VGND VPWR VPWR sky130_fd_sc_hd__decap_3
XFILLER_39_582 VGND VGND VPWR VPWR sky130_fd_sc_hd__decap_3
XFILLER_73_327 VGND VGND VPWR VPWR sky130_fd_sc_hd__decap_3
XFILLER_85_198 VGND VGND VPWR VPWR sky130_fd_sc_hd__decap_3
XFILLER_54_563 VGND VGND VPWR VPWR sky130_fd_sc_hd__decap_3
XFILLER_14_438 VGND VGND VPWR VPWR sky130_fd_sc_hd__decap_3
XFILLER_26_265 VGND VGND VPWR VPWR sky130_fd_sc_hd__decap_3
XFILLER_81_382 VGND VGND VPWR VPWR sky130_fd_sc_hd__decap_3
XFILLER_53_57 VGND VGND VPWR VPWR sky130_fd_sc_hd__decap_3
XFILLER_10_655 VGND VGND VPWR VPWR sky130_fd_sc_hd__decap_3
XFILLER_108_521 VGND VGND VPWR VPWR sky130_fd_sc_hd__decap_3
XFILLER_5_125 VGND VGND VPWR VPWR sky130_fd_sc_hd__decap_3
XFILLER_6_648 VGND VGND VPWR VPWR sky130_fd_sc_hd__decap_3
XFILLER_5_169 VGND VGND VPWR VPWR sky130_fd_sc_hd__decap_3
XTAP_TAPCELL_ROW_114_1616 VGND VPWR sky130_fd_sc_hd__tapvpwrvgnd_1
XFILLER_108_598 VGND VGND VPWR VPWR sky130_fd_sc_hd__decap_3
XFILLER_78_32 VGND VGND VPWR VPWR sky130_fd_sc_hd__decap_3
XFILLER_1_331 VGND VGND VPWR VPWR sky130_fd_sc_hd__decap_3
XFILLER_78_76 VGND VGND VPWR VPWR sky130_fd_sc_hd__decap_3
XFILLER_110_229 VGND VGND VPWR VPWR sky130_fd_sc_hd__decap_3
XFILLER_1_375 VGND VGND VPWR VPWR sky130_fd_sc_hd__decap_3
XFILLER_77_600 VGND VGND VPWR VPWR sky130_fd_sc_hd__decap_3
XFILLER_103_281 VGND VGND VPWR VPWR sky130_fd_sc_hd__decap_3
XFILLER_49_346 VGND VGND VPWR VPWR sky130_fd_sc_hd__fill_2
XFILLER_37_508 VGND VGND VPWR VPWR sky130_fd_sc_hd__fill_1
XFILLER_77_688 VGND VGND VPWR VPWR sky130_fd_sc_hd__decap_3
XFILLER_94_42 VGND VGND VPWR VPWR sky130_fd_sc_hd__decap_3
XFILLER_17_210 VGND VGND VPWR VPWR sky130_fd_sc_hd__decap_3
XFILLER_57_390 VGND VGND VPWR VPWR sky130_fd_sc_hd__fill_2
XFILLER_64_327 VGND VGND VPWR VPWR sky130_fd_sc_hd__decap_3
XFILLER_64_349 VGND VGND VPWR VPWR sky130_fd_sc_hd__decap_3
XFILLER_91_113 VGND VGND VPWR VPWR sky130_fd_sc_hd__decap_3
XFILLER_94_64 VGND VGND VPWR VPWR sky130_fd_sc_hd__decap_3
XFILLER_17_243 VGND VGND VPWR VPWR sky130_fd_sc_hd__decap_3
XFILLER_91_146 VGND VGND VPWR VPWR sky130_fd_sc_hd__decap_3
XFILLER_92_669 VGND VGND VPWR VPWR sky130_fd_sc_hd__decap_3
XFILLER_17_276 VGND VGND VPWR VPWR sky130_fd_sc_hd__decap_3
XFILLER_32_224 VGND VGND VPWR VPWR sky130_fd_sc_hd__decap_3
XTAP_TAPCELL_ROW_15_433 VGND VPWR sky130_fd_sc_hd__tapvpwrvgnd_1
XTAP_TAPCELL_ROW_43_764 VGND VPWR sky130_fd_sc_hd__tapvpwrvgnd_1
XFILLER_13_482 VGND VGND VPWR VPWR sky130_fd_sc_hd__fill_1
XFILLER_43_90 VGND VGND VPWR VPWR sky130_fd_sc_hd__decap_3
X_3680_ _3677_/Y _3902_/A2 _3826_/B1 _3679_/Y VGND VGND VPWR VPWR _3680_/X sky130_fd_sc_hd__a22o_2
X_5350_ _5350_/A0 _5131_/X _5350_/S VGND VGND VPWR VPWR _7156_/D sky130_fd_sc_hd__mux2_2
XFILLER_114_524 VGND VGND VPWR VPWR sky130_fd_sc_hd__fill_2
XFILLER_5_670 VGND VGND VPWR VPWR sky130_fd_sc_hd__fill_2
X_4301_ _7352_/Q _4338_/B1 _4339_/B1 _7160_/Q _4300_/X VGND VGND VPWR VPWR _4301_/X
+ sky130_fd_sc_hd__a221o_2
XFILLER_114_557 VGND VGND VPWR VPWR sky130_fd_sc_hd__decap_3
X_7020_ _7363_/CLK _7020_/D _6300_/Y VGND VGND VPWR VPWR _7020_/Q sky130_fd_sc_hd__dfrtp_2
X_4232_ _4228_/X _4231_/X _4327_/A VGND VGND VPWR VPWR _4628_/A sky130_fd_sc_hd__o21a_2
XFILLER_99_257 VGND VGND VPWR VPWR sky130_fd_sc_hd__fill_1
XFILLER_4_62 VGND VGND VPWR VPWR sky130_fd_sc_hd__decap_3
XFILLER_68_611 VGND VGND VPWR VPWR sky130_fd_sc_hd__decap_3
XFILLER_68_622 VGND VGND VPWR VPWR sky130_fd_sc_hd__decap_3
Xclkbuf_leaf_4_clk clkbuf_leaf_4_clk/A VGND VGND VPWR VPWR _7330_/CLK sky130_fd_sc_hd__clkbuf_16
XFILLER_67_132 VGND VGND VPWR VPWR sky130_fd_sc_hd__decap_3
X_4163_ _7073_/Q _4265_/B _4205_/A VGND VGND VPWR VPWR _4203_/B sky130_fd_sc_hd__o21a_2
XFILLER_55_305 VGND VGND VPWR VPWR sky130_fd_sc_hd__decap_3
XFILLER_83_614 VGND VGND VPWR VPWR sky130_fd_sc_hd__fill_2
XFILLER_95_452 VGND VGND VPWR VPWR sky130_fd_sc_hd__decap_3
XFILLER_95_485 VGND VGND VPWR VPWR sky130_fd_sc_hd__decap_3
X_4094_ _4095_/A _4210_/B VGND VGND VPWR VPWR _4096_/A sky130_fd_sc_hd__or2_2
XFILLER_55_327 VGND VGND VPWR VPWR sky130_fd_sc_hd__decap_3
XFILLER_55_349 VGND VGND VPWR VPWR sky130_fd_sc_hd__decap_3
XFILLER_67_198 VGND VGND VPWR VPWR sky130_fd_sc_hd__fill_2
XFILLER_82_124 VGND VGND VPWR VPWR sky130_fd_sc_hd__decap_3
XFILLER_83_669 VGND VGND VPWR VPWR sky130_fd_sc_hd__decap_3
XFILLER_23_213 VGND VGND VPWR VPWR sky130_fd_sc_hd__decap_3
XFILLER_36_585 VGND VGND VPWR VPWR sky130_fd_sc_hd__decap_3
XFILLER_63_382 VGND VGND VPWR VPWR sky130_fd_sc_hd__decap_3
XFILLER_91_691 VGND VGND VPWR VPWR sky130_fd_sc_hd__fill_1
XFILLER_63_393 VGND VGND VPWR VPWR sky130_fd_sc_hd__fill_1
Xplace382 _3373_/X VGND VGND VPWR VPWR _3429_/A sky130_fd_sc_hd__buf_2
Xplace371 _4799_/A VGND VGND VPWR VPWR _5151_/A sky130_fd_sc_hd__buf_2
Xplace360 _3409_/X VGND VGND VPWR VPWR _4352_/B1 sky130_fd_sc_hd__buf_2
X_6804_ _7406_/CLK _6804_/D VGND VGND VPWR VPWR _6804_/Q sky130_fd_sc_hd__dfxtp_2
X_4996_ _3833_/S _5657_/D _3817_/X _3346_/A VGND VGND VPWR VPWR _4996_/X sky130_fd_sc_hd__o211a_2
XFILLER_11_408 VGND VGND VPWR VPWR sky130_fd_sc_hd__decap_3
XFILLER_23_268 VGND VGND VPWR VPWR sky130_fd_sc_hd__decap_3
XFILLER_23_27 VGND VGND VPWR VPWR sky130_fd_sc_hd__decap_3
Xplace393 _5327_/S VGND VGND VPWR VPWR _5323_/S sky130_fd_sc_hd__buf_2
X_6735_ _6911_/CLK _6735_/D VGND VGND VPWR VPWR _6735_/Q sky130_fd_sc_hd__dfxtp_2
X_3947_ _7366_/Q _4491_/A0 _3947_/S VGND VGND VPWR VPWR _7366_/D sky130_fd_sc_hd__mux2_2
XFILLER_31_290 VGND VGND VPWR VPWR sky130_fd_sc_hd__decap_3
X_6666_ _6670_/A VGND VGND VPWR VPWR _6666_/Y sky130_fd_sc_hd__inv_2
X_3878_ _6729_/Q _3878_/A2 _3878_/B1 _6741_/Q VGND VGND VPWR VPWR _3878_/X sky130_fd_sc_hd__a22o_2
X_6597_ _6635_/A VGND VGND VPWR VPWR _6597_/Y sky130_fd_sc_hd__inv_2
X_5617_ _5617_/A _5634_/B VGND VGND VPWR VPWR _7019_/D sky130_fd_sc_hd__and2_2
XFILLER_2_106 VGND VGND VPWR VPWR sky130_fd_sc_hd__decap_3
XFILLER_3_629 VGND VGND VPWR VPWR sky130_fd_sc_hd__decap_3
XFILLER_105_546 VGND VGND VPWR VPWR sky130_fd_sc_hd__decap_3
XFILLER_2_139 VGND VGND VPWR VPWR sky130_fd_sc_hd__fill_1
X_7218_ _7322_/CLK _7218_/D _6498_/Y VGND VGND VPWR VPWR _7218_/Q sky130_fd_sc_hd__dfrtp_2
XFILLER_48_13 VGND VGND VPWR VPWR sky130_fd_sc_hd__decap_3
XFILLER_59_644 VGND VGND VPWR VPWR sky130_fd_sc_hd__decap_3
X_7149_ _7372_/CLK _7149_/D _6429_/Y VGND VGND VPWR VPWR _7149_/Q sky130_fd_sc_hd__dfrtp_2
XFILLER_100_240 VGND VGND VPWR VPWR sky130_fd_sc_hd__decap_3
XFILLER_48_68 VGND VGND VPWR VPWR sky130_fd_sc_hd__fill_2
XFILLER_58_165 VGND VGND VPWR VPWR sky130_fd_sc_hd__decap_3
XFILLER_59_688 VGND VGND VPWR VPWR sky130_fd_sc_hd__decap_3
XFILLER_86_463 VGND VGND VPWR VPWR sky130_fd_sc_hd__decap_3
XFILLER_100_284 VGND VGND VPWR VPWR sky130_fd_sc_hd__decap_3
XFILLER_104_41 VGND VGND VPWR VPWR sky130_fd_sc_hd__decap_3
XFILLER_104_63 VGND VGND VPWR VPWR sky130_fd_sc_hd__decap_3
XFILLER_46_338 VGND VGND VPWR VPWR sky130_fd_sc_hd__decap_3
XFILLER_64_12 VGND VGND VPWR VPWR sky130_fd_sc_hd__decap_3
XFILLER_73_113 VGND VGND VPWR VPWR sky130_fd_sc_hd__decap_3
XPHY_EDGE_ROW_100_Left_217 VGND VGND VPWR VPWR sky130_fd_sc_hd__decap_3
XFILLER_104_85 VGND VGND VPWR VPWR sky130_fd_sc_hd__decap_3
XFILLER_39_390 VGND VGND VPWR VPWR sky130_fd_sc_hd__fill_2
XFILLER_61_308 VGND VGND VPWR VPWR sky130_fd_sc_hd__decap_3
XFILLER_27_585 VGND VGND VPWR VPWR sky130_fd_sc_hd__decap_3
XFILLER_54_371 VGND VGND VPWR VPWR sky130_fd_sc_hd__decap_3
XTAP_TAPCELL_ROW_64_1014 VGND VPWR sky130_fd_sc_hd__tapvpwrvgnd_1
XFILLER_14_224 VGND VGND VPWR VPWR sky130_fd_sc_hd__decap_3
XTAP_TAPCELL_ROW_64_1025 VGND VPWR sky130_fd_sc_hd__tapvpwrvgnd_1
XFILLER_9_18 VGND VGND VPWR VPWR sky130_fd_sc_hd__decap_3
XFILLER_80_44 VGND VGND VPWR VPWR sky130_fd_sc_hd__decap_3
Xfanout50 fanout51/X VGND VGND VPWR VPWR _6388_/A sky130_fd_sc_hd__buf_2
Xfanout61 _6587_/A VGND VGND VPWR VPWR _6584_/A sky130_fd_sc_hd__buf_2
Xfanout72 _6652_/A VGND VGND VPWR VPWR fanout72/X sky130_fd_sc_hd__clkdlybuf4s25_1
XTAP_TAPCELL_ROW_40_734 VGND VPWR sky130_fd_sc_hd__tapvpwrvgnd_1
XFILLER_13_60 VGND VGND VPWR VPWR sky130_fd_sc_hd__decap_3
XFILLER_22_290 VGND VGND VPWR VPWR sky130_fd_sc_hd__decap_3
XFILLER_6_401 VGND VGND VPWR VPWR sky130_fd_sc_hd__fill_2
XFILLER_80_88 VGND VGND VPWR VPWR sky130_fd_sc_hd__decap_3
XFILLER_6_412 VGND VGND VPWR VPWR sky130_fd_sc_hd__decap_3
XFILLER_108_340 VGND VGND VPWR VPWR sky130_fd_sc_hd__decap_3
XTAP_TAPCELL_ROW_20_491 VGND VPWR sky130_fd_sc_hd__tapvpwrvgnd_1
XFILLER_2_651 VGND VGND VPWR VPWR sky130_fd_sc_hd__decap_3
XTAP_TAPCELL_ROW_75_1154 VGND VPWR sky130_fd_sc_hd__tapvpwrvgnd_1
XFILLER_111_505 VGND VGND VPWR VPWR sky130_fd_sc_hd__decap_3
XFILLER_111_538 VGND VGND VPWR VPWR sky130_fd_sc_hd__fill_1
XFILLER_2_684 VGND VGND VPWR VPWR sky130_fd_sc_hd__decap_3
XFILLER_1_172 VGND VGND VPWR VPWR sky130_fd_sc_hd__fill_1
XFILLER_1_194 VGND VGND VPWR VPWR sky130_fd_sc_hd__fill_2
XFILLER_49_110 VGND VGND VPWR VPWR sky130_fd_sc_hd__fill_2
XFILLER_49_132 VGND VGND VPWR VPWR sky130_fd_sc_hd__decap_3
XFILLER_96_249 VGND VGND VPWR VPWR sky130_fd_sc_hd__decap_3
XFILLER_65_614 VGND VGND VPWR VPWR sky130_fd_sc_hd__fill_2
XFILLER_77_452 VGND VGND VPWR VPWR sky130_fd_sc_hd__decap_3
XFILLER_64_124 VGND VGND VPWR VPWR sky130_fd_sc_hd__decap_3
XFILLER_65_647 VGND VGND VPWR VPWR sky130_fd_sc_hd__decap_3
XFILLER_77_485 VGND VGND VPWR VPWR sky130_fd_sc_hd__decap_3
XFILLER_92_411 VGND VGND VPWR VPWR sky130_fd_sc_hd__decap_3
XTAP_TAPCELL_ROW_48_823 VGND VPWR sky130_fd_sc_hd__tapvpwrvgnd_1
XFILLER_18_530 VGND VGND VPWR VPWR sky130_fd_sc_hd__fill_2
XFILLER_80_606 VGND VGND VPWR VPWR sky130_fd_sc_hd__decap_3
XFILLER_92_477 VGND VGND VPWR VPWR sky130_fd_sc_hd__decap_3
Xclkbuf_3_7__f_clk clkbuf_0_clk/X VGND VGND VPWR VPWR clkload3/A sky130_fd_sc_hd__clkbuf_16
XFILLER_33_511 VGND VGND VPWR VPWR sky130_fd_sc_hd__decap_3
XFILLER_80_639 VGND VGND VPWR VPWR sky130_fd_sc_hd__decap_3
XFILLER_45_382 VGND VGND VPWR VPWR sky130_fd_sc_hd__fill_1
XFILLER_45_393 VGND VGND VPWR VPWR sky130_fd_sc_hd__fill_1
XFILLER_60_330 VGND VGND VPWR VPWR sky130_fd_sc_hd__decap_3
X_4850_ _4142_/X _4849_/Y _4633_/A VGND VGND VPWR VPWR _4850_/Y sky130_fd_sc_hd__o21ai_2
XTAP_TAPCELL_ROW_86_1283 VGND VPWR sky130_fd_sc_hd__tapvpwrvgnd_1
XTAP_TAPCELL_ROW_28_591 VGND VPWR sky130_fd_sc_hd__tapvpwrvgnd_1
XFILLER_60_374 VGND VGND VPWR VPWR sky130_fd_sc_hd__decap_3
X_3801_ _3735_/X _3798_/X _3800_/X _3714_/X VGND VGND VPWR VPWR _3801_/X sky130_fd_sc_hd__a22o_2
XFILLER_20_227 VGND VGND VPWR VPWR sky130_fd_sc_hd__decap_3
X_6520_ _6616_/A VGND VGND VPWR VPWR _6520_/Y sky130_fd_sc_hd__inv_2
X_4781_ _4444_/X _4780_/Y _4413_/A VGND VGND VPWR VPWR _4781_/X sky130_fd_sc_hd__o21a_2
XFILLER_13_290 VGND VGND VPWR VPWR sky130_fd_sc_hd__decap_3
XFILLER_20_249 VGND VGND VPWR VPWR sky130_fd_sc_hd__decap_3
X_3732_ _6776_/Q _3884_/A2 _3883_/A2 _6764_/Q _3731_/X VGND VGND VPWR VPWR _3732_/X
+ sky130_fd_sc_hd__a221o_2
Xclkload20 _6976_/CLK VGND VGND VPWR VPWR clkload20/X sky130_fd_sc_hd__clkbuf_1
X_6451_ _6483_/A VGND VGND VPWR VPWR _6451_/Y sky130_fd_sc_hd__inv_2
Xclkload31 _7406_/CLK VGND VGND VPWR VPWR clkload31/X sky130_fd_sc_hd__clkbuf_1
X_6382_ _6539_/A VGND VGND VPWR VPWR _6382_/Y sky130_fd_sc_hd__inv_2
X_5402_ _5402_/A0 _5027_/X _5417_/S VGND VGND VPWR VPWR _7132_/D sky130_fd_sc_hd__mux2_2
X_5333_ _7164_/Q _5027_/X _5350_/S VGND VGND VPWR VPWR _7164_/D sky130_fd_sc_hd__mux2_2
X_3594_ _4292_/A _3594_/B VGND VGND VPWR VPWR _3594_/Y sky130_fd_sc_hd__nor2_2
XFILLER_102_505 VGND VGND VPWR VPWR sky130_fd_sc_hd__decap_3
XFILLER_114_365 VGND VGND VPWR VPWR sky130_fd_sc_hd__decap_3
X_5264_ _5264_/A0 _4997_/X _5292_/S VGND VGND VPWR VPWR _7198_/D sky130_fd_sc_hd__mux2_2
XFILLER_87_249 VGND VGND VPWR VPWR sky130_fd_sc_hd__decap_3
X_7003_ _7005_/CLK _7003_/D _6283_/Y VGND VGND VPWR VPWR _7003_/Q sky130_fd_sc_hd__dfrtp_2
X_4215_ _7260_/Q _4356_/A2 _4212_/X _4214_/X VGND VGND VPWR VPWR _4371_/A sky130_fd_sc_hd__a211o_2
XFILLER_56_603 VGND VGND VPWR VPWR sky130_fd_sc_hd__decap_3
XFILLER_68_452 VGND VGND VPWR VPWR sky130_fd_sc_hd__decap_3
X_4146_ _7234_/Q _4349_/B1 _4348_/B1 _7138_/Q VGND VGND VPWR VPWR _4146_/X sky130_fd_sc_hd__a22o_2
XFILLER_18_27 VGND VGND VPWR VPWR sky130_fd_sc_hd__fill_1
XFILLER_18_38 VGND VGND VPWR VPWR sky130_fd_sc_hd__decap_3
XFILLER_55_113 VGND VGND VPWR VPWR sky130_fd_sc_hd__decap_3
XFILLER_56_636 VGND VGND VPWR VPWR sky130_fd_sc_hd__decap_3
XFILLER_95_271 VGND VGND VPWR VPWR sky130_fd_sc_hd__fill_2
XFILLER_28_349 VGND VGND VPWR VPWR sky130_fd_sc_hd__decap_3
XFILLER_55_146 VGND VGND VPWR VPWR sky130_fd_sc_hd__fill_2
XFILLER_56_669 VGND VGND VPWR VPWR sky130_fd_sc_hd__decap_3
XFILLER_71_606 VGND VGND VPWR VPWR sky130_fd_sc_hd__decap_3
XFILLER_71_617 VGND VGND VPWR VPWR sky130_fd_sc_hd__decap_3
XFILLER_83_455 VGND VGND VPWR VPWR sky130_fd_sc_hd__fill_1
X_4077_ _7243_/Q _4433_/B _4434_/A2 _7115_/Q _4076_/X VGND VGND VPWR VPWR _4077_/X
+ sky130_fd_sc_hd__a221o_2
XFILLER_24_511 VGND VGND VPWR VPWR sky130_fd_sc_hd__decap_3
XFILLER_83_499 VGND VGND VPWR VPWR sky130_fd_sc_hd__decap_3
XFILLER_24_533 VGND VGND VPWR VPWR sky130_fd_sc_hd__decap_3
XFILLER_34_26 VGND VGND VPWR VPWR sky130_fd_sc_hd__fill_2
XFILLER_34_48 VGND VGND VPWR VPWR sky130_fd_sc_hd__fill_2
XFILLER_51_374 VGND VGND VPWR VPWR sky130_fd_sc_hd__decap_3
XFILLER_51_385 VGND VGND VPWR VPWR sky130_fd_sc_hd__decap_3
XFILLER_51_396 VGND VGND VPWR VPWR sky130_fd_sc_hd__decap_3
X_4979_ _4979_/A0 _4978_/X _5028_/S VGND VGND VPWR VPWR _7263_/D sky130_fd_sc_hd__mux2_2
XFILLER_7_209 VGND VGND VPWR VPWR sky130_fd_sc_hd__decap_3
Xclkload3 clkload3/A VGND VGND VPWR VPWR clkload3/X sky130_fd_sc_hd__clkbuf_16
X_6718_ _7406_/CLK _6718_/D VGND VGND VPWR VPWR _6718_/Q sky130_fd_sc_hd__dfxtp_2
XFILLER_50_25 VGND VGND VPWR VPWR sky130_fd_sc_hd__decap_3
XFILLER_50_47 VGND VGND VPWR VPWR sky130_fd_sc_hd__decap_3
X_6649_ _6651_/A VGND VGND VPWR VPWR _6649_/Y sky130_fd_sc_hd__inv_2
XFILLER_3_426 VGND VGND VPWR VPWR sky130_fd_sc_hd__decap_3
XFILLER_105_321 VGND VGND VPWR VPWR sky130_fd_sc_hd__decap_3
XFILLER_59_23 VGND VGND VPWR VPWR sky130_fd_sc_hd__decap_3
XFILLER_105_376 VGND VGND VPWR VPWR sky130_fd_sc_hd__decap_3
XFILLER_59_45 VGND VGND VPWR VPWR sky130_fd_sc_hd__decap_3
XFILLER_59_430 VGND VGND VPWR VPWR sky130_fd_sc_hd__decap_3
XFILLER_47_614 VGND VGND VPWR VPWR sky130_fd_sc_hd__fill_2
XFILLER_93_219 VGND VGND VPWR VPWR sky130_fd_sc_hd__fill_2
XFILLER_101_571 VGND VGND VPWR VPWR sky130_fd_sc_hd__decap_3
XFILLER_115_84 VGND VGND VPWR VPWR sky130_fd_sc_hd__decap_3
XFILLER_19_327 VGND VGND VPWR VPWR sky130_fd_sc_hd__fill_2
XFILLER_47_647 VGND VGND VPWR VPWR sky130_fd_sc_hd__decap_3
XFILLER_75_22 VGND VGND VPWR VPWR sky130_fd_sc_hd__decap_3
XFILLER_75_55 VGND VGND VPWR VPWR sky130_fd_sc_hd__fill_1
XFILLER_86_271 VGND VGND VPWR VPWR sky130_fd_sc_hd__fill_1
XTAP_TAPCELL_ROW_70_1095 VGND VPWR sky130_fd_sc_hd__tapvpwrvgnd_1
XFILLER_19_349 VGND VGND VPWR VPWR sky130_fd_sc_hd__decap_3
XFILLER_75_66 VGND VGND VPWR VPWR sky130_fd_sc_hd__decap_3
XTAP_TAPCELL_ROW_109_1559 VGND VPWR sky130_fd_sc_hd__tapvpwrvgnd_1
XFILLER_15_511 VGND VGND VPWR VPWR sky130_fd_sc_hd__fill_1
XFILLER_27_371 VGND VGND VPWR VPWR sky130_fd_sc_hd__decap_3
XFILLER_46_168 VGND VGND VPWR VPWR sky130_fd_sc_hd__decap_3
XFILLER_61_116 VGND VGND VPWR VPWR sky130_fd_sc_hd__decap_3
XFILLER_62_617 VGND VGND VPWR VPWR sky130_fd_sc_hd__decap_3
XFILLER_74_477 VGND VGND VPWR VPWR sky130_fd_sc_hd__decap_3
XFILLER_75_99 VGND VGND VPWR VPWR sky130_fd_sc_hd__decap_3
XFILLER_27_393 VGND VGND VPWR VPWR sky130_fd_sc_hd__decap_3
XFILLER_55_691 VGND VGND VPWR VPWR sky130_fd_sc_hd__fill_1
XFILLER_61_138 VGND VGND VPWR VPWR sky130_fd_sc_hd__decap_3
XFILLER_42_341 VGND VGND VPWR VPWR sky130_fd_sc_hd__decap_3
XTAP_TAPCELL_ROW_25_550 VGND VPWR sky130_fd_sc_hd__tapvpwrvgnd_1
XTAP_TAPCELL_ROW_53_892 VGND VPWR sky130_fd_sc_hd__tapvpwrvgnd_1
XFILLER_24_92 VGND VGND VPWR VPWR sky130_fd_sc_hd__decap_3
XFILLER_30_558 VGND VGND VPWR VPWR sky130_fd_sc_hd__decap_3
XFILLER_10_271 VGND VGND VPWR VPWR sky130_fd_sc_hd__decap_3
XFILLER_6_253 VGND VGND VPWR VPWR sky130_fd_sc_hd__fill_1
XFILLER_109_671 VGND VGND VPWR VPWR sky130_fd_sc_hd__fill_1
XFILLER_109_682 VGND VGND VPWR VPWR sky130_fd_sc_hd__decap_3
XFILLER_6_286 VGND VGND VPWR VPWR sky130_fd_sc_hd__decap_3
XFILLER_108_192 VGND VGND VPWR VPWR sky130_fd_sc_hd__decap_3
XFILLER_69_216 VGND VGND VPWR VPWR sky130_fd_sc_hd__fill_2
XFILLER_97_514 VGND VGND VPWR VPWR sky130_fd_sc_hd__decap_3
XFILLER_111_346 VGND VGND VPWR VPWR sky130_fd_sc_hd__decap_3
XFILLER_69_249 VGND VGND VPWR VPWR sky130_fd_sc_hd__fill_2
XFILLER_111_379 VGND VGND VPWR VPWR sky130_fd_sc_hd__fill_2
XFILLER_1_41 VGND VGND VPWR VPWR sky130_fd_sc_hd__decap_3
XFILLER_38_636 VGND VGND VPWR VPWR sky130_fd_sc_hd__decap_3
XFILLER_65_422 VGND VGND VPWR VPWR sky130_fd_sc_hd__decap_3
XTAP_TAPCELL_ROW_88_1312 VGND VPWR sky130_fd_sc_hd__tapvpwrvgnd_1
XFILLER_1_63 VGND VGND VPWR VPWR sky130_fd_sc_hd__decap_3
XFILLER_65_444 VGND VGND VPWR VPWR sky130_fd_sc_hd__decap_3
XFILLER_65_455 VGND VGND VPWR VPWR sky130_fd_sc_hd__fill_2
XFILLER_65_466 VGND VGND VPWR VPWR sky130_fd_sc_hd__decap_3
XFILLER_18_360 VGND VGND VPWR VPWR sky130_fd_sc_hd__decap_3
XFILLER_1_96 VGND VGND VPWR VPWR sky130_fd_sc_hd__decap_3
XFILLER_53_617 VGND VGND VPWR VPWR sky130_fd_sc_hd__decap_3
XFILLER_65_499 VGND VGND VPWR VPWR sky130_fd_sc_hd__decap_3
XFILLER_80_458 VGND VGND VPWR VPWR sky130_fd_sc_hd__fill_1
XFILLER_61_650 VGND VGND VPWR VPWR sky130_fd_sc_hd__decap_3
XFILLER_80_469 VGND VGND VPWR VPWR sky130_fd_sc_hd__decap_3
XFILLER_21_547 VGND VGND VPWR VPWR sky130_fd_sc_hd__fill_1
XFILLER_33_374 VGND VGND VPWR VPWR sky130_fd_sc_hd__fill_2
X_4833_ _7001_/Q _4687_/B _4777_/A VGND VGND VPWR VPWR _4834_/B sky130_fd_sc_hd__o21ai_2
XFILLER_21_558 VGND VGND VPWR VPWR sky130_fd_sc_hd__fill_2
XFILLER_60_193 VGND VGND VPWR VPWR sky130_fd_sc_hd__decap_3
X_4764_ _4938_/A _4764_/B VGND VGND VPWR VPWR _4788_/A sky130_fd_sc_hd__nor2_2
X_6503_ _6570_/A VGND VGND VPWR VPWR _6503_/Y sky130_fd_sc_hd__inv_2
XTAP_TAPCELL_ROW_99_1441 VGND VPWR sky130_fd_sc_hd__tapvpwrvgnd_1
X_6434_ _6570_/A VGND VGND VPWR VPWR _6434_/Y sky130_fd_sc_hd__inv_2
X_4695_ _7008_/Q _4728_/A _4694_/Y _4909_/A VGND VGND VPWR VPWR _4695_/X sky130_fd_sc_hd__a211o_2
XFILLER_106_129 VGND VGND VPWR VPWR sky130_fd_sc_hd__decap_3
XFILLER_115_641 VGND VGND VPWR VPWR sky130_fd_sc_hd__decap_3
X_6365_ _6366_/A VGND VGND VPWR VPWR _6365_/Y sky130_fd_sc_hd__inv_2
X_3577_ _7060_/Q _3577_/B VGND VGND VPWR VPWR _3591_/C sky130_fd_sc_hd__nor2_2
XFILLER_0_418 VGND VGND VPWR VPWR sky130_fd_sc_hd__fill_2
XFILLER_114_162 VGND VGND VPWR VPWR sky130_fd_sc_hd__decap_3
X_6296_ _6539_/A VGND VGND VPWR VPWR _6296_/Y sky130_fd_sc_hd__inv_2
XFILLER_102_335 VGND VGND VPWR VPWR sky130_fd_sc_hd__decap_3
XFILLER_114_195 VGND VGND VPWR VPWR sky130_fd_sc_hd__fill_1
XFILLER_29_15 VGND VGND VPWR VPWR sky130_fd_sc_hd__decap_3
XFILLER_88_536 VGND VGND VPWR VPWR sky130_fd_sc_hd__decap_3
X_5247_ _5247_/A0 _4864_/X _5262_/S VGND VGND VPWR VPWR _7206_/D sky130_fd_sc_hd__mux2_2
XFILLER_102_368 VGND VGND VPWR VPWR sky130_fd_sc_hd__decap_3
XFILLER_29_614 VGND VGND VPWR VPWR sky130_fd_sc_hd__fill_2
XFILLER_29_636 VGND VGND VPWR VPWR sky130_fd_sc_hd__fill_2
XFILLER_28_124 VGND VGND VPWR VPWR sky130_fd_sc_hd__decap_3
XFILLER_28_135 VGND VGND VPWR VPWR sky130_fd_sc_hd__decap_3
XFILLER_56_466 VGND VGND VPWR VPWR sky130_fd_sc_hd__decap_3
X_4129_ _7299_/Q _4501_/S _4196_/A2 _7363_/Q _4419_/C1 VGND VGND VPWR VPWR _4129_/X
+ sky130_fd_sc_hd__a221o_2
XFILLER_28_168 VGND VGND VPWR VPWR sky130_fd_sc_hd__fill_1
XFILLER_43_116 VGND VGND VPWR VPWR sky130_fd_sc_hd__decap_3
XFILLER_44_639 VGND VGND VPWR VPWR sky130_fd_sc_hd__decap_3
XFILLER_45_36 VGND VGND VPWR VPWR sky130_fd_sc_hd__decap_3
XFILLER_71_414 VGND VGND VPWR VPWR sky130_fd_sc_hd__decap_3
XFILLER_83_274 VGND VGND VPWR VPWR sky130_fd_sc_hd__fill_2
XTAP_TAPCELL_ROW_3_289 VGND VPWR sky130_fd_sc_hd__tapvpwrvgnd_1
XFILLER_71_436 VGND VGND VPWR VPWR sky130_fd_sc_hd__decap_3
XFILLER_71_458 VGND VGND VPWR VPWR sky130_fd_sc_hd__decap_3
XFILLER_24_352 VGND VGND VPWR VPWR sky130_fd_sc_hd__fill_1
XFILLER_52_672 VGND VGND VPWR VPWR sky130_fd_sc_hd__decap_3
XFILLER_71_469 VGND VGND VPWR VPWR sky130_fd_sc_hd__decap_3
XFILLER_12_514 VGND VGND VPWR VPWR sky130_fd_sc_hd__fill_1
XFILLER_51_193 VGND VGND VPWR VPWR sky130_fd_sc_hd__decap_3
XFILLER_61_46 VGND VGND VPWR VPWR sky130_fd_sc_hd__decap_3
XFILLER_61_57 VGND VGND VPWR VPWR sky130_fd_sc_hd__decap_3
XTAP_TAPCELL_ROW_50_851 VGND VPWR sky130_fd_sc_hd__tapvpwrvgnd_1
XTAP_TAPCELL_ROW_22_520 VGND VPWR sky130_fd_sc_hd__tapvpwrvgnd_1
XFILLER_3_234 VGND VGND VPWR VPWR sky130_fd_sc_hd__decap_3
XFILLER_105_162 VGND VGND VPWR VPWR sky130_fd_sc_hd__decap_3
XFILLER_106_663 VGND VGND VPWR VPWR sky130_fd_sc_hd__decap_3
XFILLER_10_50 VGND VGND VPWR VPWR sky130_fd_sc_hd__decap_3
XFILLER_3_267 VGND VGND VPWR VPWR sky130_fd_sc_hd__decap_3
XFILLER_79_514 VGND VGND VPWR VPWR sky130_fd_sc_hd__decap_3
XTAP_TAPCELL_ROW_72_1113 VGND VPWR sky130_fd_sc_hd__tapvpwrvgnd_1
XFILLER_10_83 VGND VGND VPWR VPWR sky130_fd_sc_hd__fill_1
XFILLER_86_43 VGND VGND VPWR VPWR sky130_fd_sc_hd__decap_3
XFILLER_94_517 VGND VGND VPWR VPWR sky130_fd_sc_hd__decap_3
XFILLER_19_102 VGND VGND VPWR VPWR sky130_fd_sc_hd__decap_3
XFILLER_19_113 VGND VGND VPWR VPWR sky130_fd_sc_hd__fill_2
XFILLER_47_411 VGND VGND VPWR VPWR sky130_fd_sc_hd__fill_2
XFILLER_47_422 VGND VGND VPWR VPWR sky130_fd_sc_hd__fill_2
XFILLER_86_76 VGND VGND VPWR VPWR sky130_fd_sc_hd__decap_3
XFILLER_101_390 VGND VGND VPWR VPWR sky130_fd_sc_hd__fill_2
XFILLER_19_70 VGND VGND VPWR VPWR sky130_fd_sc_hd__decap_3
XTAP_TAPCELL_ROW_58_951 VGND VPWR sky130_fd_sc_hd__tapvpwrvgnd_1
XFILLER_35_617 VGND VGND VPWR VPWR sky130_fd_sc_hd__fill_2
XFILLER_35_639 VGND VGND VPWR VPWR sky130_fd_sc_hd__decap_3
XFILLER_62_403 VGND VGND VPWR VPWR sky130_fd_sc_hd__decap_3
XFILLER_74_274 VGND VGND VPWR VPWR sky130_fd_sc_hd__decap_3
XFILLER_62_436 VGND VGND VPWR VPWR sky130_fd_sc_hd__decap_3
XFILLER_27_190 VGND VGND VPWR VPWR sky130_fd_sc_hd__decap_3
XFILLER_43_650 VGND VGND VPWR VPWR sky130_fd_sc_hd__decap_3
XFILLER_50_609 VGND VGND VPWR VPWR sky130_fd_sc_hd__decap_3
XTAP_TAPCELL_ROW_83_1253 VGND VPWR sky130_fd_sc_hd__tapvpwrvgnd_1
XTAP_TAPCELL_ROW_83_1242 VGND VPWR sky130_fd_sc_hd__tapvpwrvgnd_1
XFILLER_70_480 VGND VGND VPWR VPWR sky130_fd_sc_hd__decap_3
XFILLER_11_591 VGND VGND VPWR VPWR sky130_fd_sc_hd__fill_2
XFILLER_30_399 VGND VGND VPWR VPWR sky130_fd_sc_hd__decap_3
X_3500_ _4460_/A _4460_/B _3541_/B VGND VGND VPWR VPWR _3500_/Y sky130_fd_sc_hd__a21oi_2
XFILLER_116_405 VGND VGND VPWR VPWR sky130_fd_sc_hd__fill_1
XFILLER_116_427 VGND VGND VPWR VPWR sky130_fd_sc_hd__fill_2
X_4480_ _4480_/A0 _7307_/Q _4488_/S VGND VGND VPWR VPWR _7339_/D sky130_fd_sc_hd__mux2_2
XFILLER_116_449 VGND VGND VPWR VPWR sky130_fd_sc_hd__decap_3
X_3362_ _3362_/A _5670_/A _6982_/Q VGND VGND VPWR VPWR _3362_/X sky130_fd_sc_hd__or3b_2
XTAP_TAPCELL_ROW_94_1382 VGND VPWR sky130_fd_sc_hd__tapvpwrvgnd_1
XFILLER_112_622 VGND VGND VPWR VPWR sky130_fd_sc_hd__decap_3
XFILLER_97_333 VGND VGND VPWR VPWR sky130_fd_sc_hd__decap_3
X_5101_ _5101_/A _5101_/B VGND VGND VPWR VPWR _5101_/Y sky130_fd_sc_hd__nor2_2
XFILLER_111_143 VGND VGND VPWR VPWR sky130_fd_sc_hd__decap_3
XFILLER_112_666 VGND VGND VPWR VPWR sky130_fd_sc_hd__decap_3
Xhold1207 _7136_/Q VGND VGND VPWR VPWR _5394_/A0 sky130_fd_sc_hd__dlygate4sd3_1
XFILLER_111_165 VGND VGND VPWR VPWR sky130_fd_sc_hd__decap_3
XFILLER_97_388 VGND VGND VPWR VPWR sky130_fd_sc_hd__fill_1
XFILLER_97_399 VGND VGND VPWR VPWR sky130_fd_sc_hd__decap_3
X_5032_ _5032_/A _5032_/B VGND VGND VPWR VPWR _5032_/Y sky130_fd_sc_hd__xnor2_2
XFILLER_25_105 VGND VGND VPWR VPWR sky130_fd_sc_hd__decap_3
XFILLER_38_477 VGND VGND VPWR VPWR sky130_fd_sc_hd__fill_1
XFILLER_53_414 VGND VGND VPWR VPWR sky130_fd_sc_hd__decap_3
XFILLER_65_274 VGND VGND VPWR VPWR sky130_fd_sc_hd__decap_3
XFILLER_93_583 VGND VGND VPWR VPWR sky130_fd_sc_hd__decap_3
XFILLER_25_149 VGND VGND VPWR VPWR sky130_fd_sc_hd__decap_3
XFILLER_65_296 VGND VGND VPWR VPWR sky130_fd_sc_hd__decap_3
XFILLER_80_222 VGND VGND VPWR VPWR sky130_fd_sc_hd__decap_3
X_6983_ _7264_/CLK _6983_/D _6263_/Y VGND VGND VPWR VPWR _6983_/Q sky130_fd_sc_hd__dfrtp_2
XTAP_TAPCELL_ROW_0_248 VGND VPWR sky130_fd_sc_hd__tapvpwrvgnd_1
XTAP_TAPCELL_ROW_0_237 VGND VPWR sky130_fd_sc_hd__tapvpwrvgnd_1
XFILLER_15_39 VGND VGND VPWR VPWR sky130_fd_sc_hd__decap_3
XFILLER_41_609 VGND VGND VPWR VPWR sky130_fd_sc_hd__decap_3
XTAP_TAPCELL_ROW_36_678 VGND VPWR sky130_fd_sc_hd__tapvpwrvgnd_1
XFILLER_80_299 VGND VGND VPWR VPWR sky130_fd_sc_hd__decap_3
XTAP_TAPCELL_ROW_36_689 VGND VPWR sky130_fd_sc_hd__tapvpwrvgnd_1
XFILLER_21_322 VGND VGND VPWR VPWR sky130_fd_sc_hd__decap_3
XFILLER_21_344 VGND VGND VPWR VPWR sky130_fd_sc_hd__decap_3
XFILLER_33_193 VGND VGND VPWR VPWR sky130_fd_sc_hd__decap_3
XFILLER_61_491 VGND VGND VPWR VPWR sky130_fd_sc_hd__decap_3
X_4816_ _3526_/B _4652_/A _4813_/A _5033_/B2 VGND VGND VPWR VPWR _4816_/X sky130_fd_sc_hd__a22o_2
X_4747_ _4739_/Y _4740_/X _4743_/X _4746_/X VGND VGND VPWR VPWR _5664_/B sky130_fd_sc_hd__o211a_2
XFILLER_110_9 VGND VGND VPWR VPWR sky130_fd_sc_hd__decap_3
X_4678_ _6988_/Q _4674_/X _5045_/B _5036_/A VGND VGND VPWR VPWR _5014_/B sky130_fd_sc_hd__a31o_2
XFILLER_107_449 VGND VGND VPWR VPWR sky130_fd_sc_hd__decap_3
X_7397_ _7397_/CLK _7397_/D _6677_/Y VGND VGND VPWR VPWR _7397_/Q sky130_fd_sc_hd__dfrtp_2
X_6417_ _6578_/A VGND VGND VPWR VPWR _6417_/Y sky130_fd_sc_hd__inv_2
X_3629_ _3682_/A VGND VGND VPWR VPWR _3629_/Y sky130_fd_sc_hd__inv_2
XFILLER_88_300 VGND VGND VPWR VPWR sky130_fd_sc_hd__decap_3
X_6348_ _6540_/A VGND VGND VPWR VPWR _6348_/Y sky130_fd_sc_hd__inv_2
XFILLER_0_204 VGND VGND VPWR VPWR sky130_fd_sc_hd__fill_2
XFILLER_0_237 VGND VGND VPWR VPWR sky130_fd_sc_hd__fill_2
XTAP_TAPCELL_ROW_8_348 VGND VPWR sky130_fd_sc_hd__tapvpwrvgnd_1
XFILLER_0_259 VGND VGND VPWR VPWR sky130_fd_sc_hd__decap_3
XFILLER_103_666 VGND VGND VPWR VPWR sky130_fd_sc_hd__decap_3
XFILLER_76_517 VGND VGND VPWR VPWR sky130_fd_sc_hd__decap_3
X_6279_ _6280_/A VGND VGND VPWR VPWR _6279_/Y sky130_fd_sc_hd__inv_2
XFILLER_29_411 VGND VGND VPWR VPWR sky130_fd_sc_hd__decap_3
XFILLER_76_539 VGND VGND VPWR VPWR sky130_fd_sc_hd__decap_3
XFILLER_88_399 VGND VGND VPWR VPWR sky130_fd_sc_hd__fill_1
XFILLER_29_433 VGND VGND VPWR VPWR sky130_fd_sc_hd__decap_3
XFILLER_29_455 VGND VGND VPWR VPWR sky130_fd_sc_hd__fill_1
XFILLER_91_509 VGND VGND VPWR VPWR sky130_fd_sc_hd__fill_2
XFILLER_17_617 VGND VGND VPWR VPWR sky130_fd_sc_hd__decap_3
XFILLER_29_477 VGND VGND VPWR VPWR sky130_fd_sc_hd__decap_3
XFILLER_44_414 VGND VGND VPWR VPWR sky130_fd_sc_hd__fill_1
XFILLER_56_241 VGND VGND VPWR VPWR sky130_fd_sc_hd__decap_3
XFILLER_56_274 VGND VGND VPWR VPWR sky130_fd_sc_hd__decap_3
XFILLER_56_57 VGND VGND VPWR VPWR sky130_fd_sc_hd__decap_3
XFILLER_56_68 VGND VGND VPWR VPWR sky130_fd_sc_hd__fill_2
XFILLER_84_550 VGND VGND VPWR VPWR sky130_fd_sc_hd__fill_2
XFILLER_84_561 VGND VGND VPWR VPWR sky130_fd_sc_hd__decap_3
XTAP_TAPCELL_ROW_55_910 VGND VPWR sky130_fd_sc_hd__tapvpwrvgnd_1
XTAP_TAPCELL_ROW_106_1518 VGND VPWR sky130_fd_sc_hd__tapvpwrvgnd_1
XFILLER_112_41 VGND VGND VPWR VPWR sky130_fd_sc_hd__decap_3
XFILLER_44_447 VGND VGND VPWR VPWR sky130_fd_sc_hd__decap_3
XFILLER_71_211 VGND VGND VPWR VPWR sky130_fd_sc_hd__decap_3
XTAP_TAPCELL_ROW_106_1529 VGND VPWR sky130_fd_sc_hd__tapvpwrvgnd_1
XFILLER_112_74 VGND VGND VPWR VPWR sky130_fd_sc_hd__decap_3
XFILLER_112_85 VGND VGND VPWR VPWR sky130_fd_sc_hd__decap_3
XFILLER_71_255 VGND VGND VPWR VPWR sky130_fd_sc_hd__decap_3
XFILLER_72_12 VGND VGND VPWR VPWR sky130_fd_sc_hd__fill_1
XFILLER_72_23 VGND VGND VPWR VPWR sky130_fd_sc_hd__decap_3
XFILLER_31_119 VGND VGND VPWR VPWR sky130_fd_sc_hd__decap_3
XFILLER_72_45 VGND VGND VPWR VPWR sky130_fd_sc_hd__decap_3
XFILLER_12_333 VGND VGND VPWR VPWR sky130_fd_sc_hd__decap_3
XFILLER_24_182 VGND VGND VPWR VPWR sky130_fd_sc_hd__decap_3
XFILLER_40_653 VGND VGND VPWR VPWR sky130_fd_sc_hd__decap_3
XFILLER_72_78 VGND VGND VPWR VPWR sky130_fd_sc_hd__decap_3
XFILLER_40_686 VGND VGND VPWR VPWR sky130_fd_sc_hd__decap_3
XFILLER_8_326 VGND VGND VPWR VPWR sky130_fd_sc_hd__fill_2
XFILLER_8_337 VGND VGND VPWR VPWR sky130_fd_sc_hd__fill_2
XFILLER_8_359 VGND VGND VPWR VPWR sky130_fd_sc_hd__decap_3
XFILLER_21_60 VGND VGND VPWR VPWR sky130_fd_sc_hd__decap_3
XFILLER_113_419 VGND VGND VPWR VPWR sky130_fd_sc_hd__decap_3
XFILLER_21_93 VGND VGND VPWR VPWR sky130_fd_sc_hd__decap_3
XFILLER_98_108 VGND VGND VPWR VPWR sky130_fd_sc_hd__decap_3
XFILLER_106_471 VGND VGND VPWR VPWR sky130_fd_sc_hd__decap_3
XFILLER_79_322 VGND VGND VPWR VPWR sky130_fd_sc_hd__decap_3
XFILLER_97_86 VGND VGND VPWR VPWR sky130_fd_sc_hd__decap_3
XFILLER_79_399 VGND VGND VPWR VPWR sky130_fd_sc_hd__decap_3
XFILLER_75_550 VGND VGND VPWR VPWR sky130_fd_sc_hd__decap_3
XFILLER_62_200 VGND VGND VPWR VPWR sky130_fd_sc_hd__decap_3
XFILLER_90_520 VGND VGND VPWR VPWR sky130_fd_sc_hd__decap_3
XFILLER_90_542 VGND VGND VPWR VPWR sky130_fd_sc_hd__decap_3
XFILLER_90_564 VGND VGND VPWR VPWR sky130_fd_sc_hd__decap_3
XFILLER_62_288 VGND VGND VPWR VPWR sky130_fd_sc_hd__decap_3
XFILLER_15_193 VGND VGND VPWR VPWR sky130_fd_sc_hd__decap_3
Xclkbuf_0_clk clk VGND VGND VPWR VPWR clkbuf_0_clk/X sky130_fd_sc_hd__clkbuf_16
X_5650_ _5650_/A VGND VGND VPWR VPWR _5650_/Y sky130_fd_sc_hd__inv_2
XTAP_TAPCELL_ROW_61_979 VGND VPWR sky130_fd_sc_hd__tapvpwrvgnd_1
XTAP_TAPCELL_ROW_33_648 VGND VPWR sky130_fd_sc_hd__tapvpwrvgnd_1
XFILLER_30_152 VGND VGND VPWR VPWR sky130_fd_sc_hd__decap_3
XFILLER_87_3 VGND VGND VPWR VPWR sky130_fd_sc_hd__decap_3
X_4601_ _7280_/Q _5157_/A0 _4601_/S VGND VGND VPWR VPWR _7280_/D sky130_fd_sc_hd__mux2_2
XFILLER_30_185 VGND VGND VPWR VPWR sky130_fd_sc_hd__decap_3
X_5581_ _5581_/A0 _5069_/X _5581_/S VGND VGND VPWR VPWR _7038_/D sky130_fd_sc_hd__mux2_2
XTAP_TAPCELL_ROW_96_1400 VGND VPWR sky130_fd_sc_hd__tapvpwrvgnd_1
XFILLER_7_51 VGND VGND VPWR VPWR sky130_fd_sc_hd__decap_3
X_7320_ clkload6/A _7320_/D _6600_/Y VGND VGND VPWR VPWR _7320_/Q sky130_fd_sc_hd__dfrtp_2
X_4532_ _4532_/A0 _7281_/Q _4532_/S VGND VGND VPWR VPWR _7313_/D sky130_fd_sc_hd__mux2_2
XFILLER_7_84 VGND VGND VPWR VPWR sky130_fd_sc_hd__decap_3
X_7251_ clkload8/A _7251_/D _6531_/Y VGND VGND VPWR VPWR _7251_/Q sky130_fd_sc_hd__dfrtp_2
X_4463_ _4460_/Y _3541_/B _5057_/A _4462_/Y VGND VGND VPWR VPWR _4463_/X sky130_fd_sc_hd__a22o_2
XFILLER_104_408 VGND VGND VPWR VPWR sky130_fd_sc_hd__decap_3
XFILLER_116_279 VGND VGND VPWR VPWR sky130_fd_sc_hd__fill_1
X_3414_ _3421_/C VGND VGND VPWR VPWR _3449_/C sky130_fd_sc_hd__inv_4
X_7182_ _7372_/CLK _7182_/D _6462_/Y VGND VGND VPWR VPWR _7182_/Q sky130_fd_sc_hd__dfrtp_2
X_4394_ _4394_/A _4394_/B _4393_/X VGND VGND VPWR VPWR _4444_/B sky130_fd_sc_hd__or3b_2
XPHY_EDGE_ROW_15_Right_15 VGND VGND VPWR VPWR sky130_fd_sc_hd__decap_3
XFILLER_97_152 VGND VGND VPWR VPWR sky130_fd_sc_hd__decap_3
X_3345_ _5642_/A _4677_/B VGND VGND VPWR VPWR _3346_/A sky130_fd_sc_hd__nor2_4
XTAP_TAPCELL_ROW_5_307 VGND VPWR sky130_fd_sc_hd__tapvpwrvgnd_1
XFILLER_98_675 VGND VGND VPWR VPWR sky130_fd_sc_hd__decap_3
Xhold1004 _7271_/Q VGND VGND VPWR VPWR _4837_/A0 sky130_fd_sc_hd__dlygate4sd3_1
Xhold1015 _7254_/Q VGND VGND VPWR VPWR _5122_/A0 sky130_fd_sc_hd__dlygate4sd3_1
XFILLER_100_669 VGND VGND VPWR VPWR sky130_fd_sc_hd__decap_3
XFILLER_97_196 VGND VGND VPWR VPWR sky130_fd_sc_hd__fill_2
Xhold1026 _7273_/Q VGND VGND VPWR VPWR _4807_/A0 sky130_fd_sc_hd__dlygate4sd3_1
Xhold1037 _7190_/Q VGND VGND VPWR VPWR _5280_/A0 sky130_fd_sc_hd__dlygate4sd3_1
Xhold1048 _7186_/Q VGND VGND VPWR VPWR _5286_/A0 sky130_fd_sc_hd__dlygate4sd3_1
X_5015_ _5015_/A _5015_/B _5015_/C VGND VGND VPWR VPWR _5015_/X sky130_fd_sc_hd__and3_2
XFILLER_85_369 VGND VGND VPWR VPWR sky130_fd_sc_hd__decap_3
Xhold1059 _7381_/Q VGND VGND VPWR VPWR _3901_/A1 sky130_fd_sc_hd__dlygate4sd3_1
XFILLER_26_436 VGND VGND VPWR VPWR sky130_fd_sc_hd__decap_3
XFILLER_53_211 VGND VGND VPWR VPWR sky130_fd_sc_hd__decap_3
XFILLER_81_520 VGND VGND VPWR VPWR sky130_fd_sc_hd__decap_3
XFILLER_14_609 VGND VGND VPWR VPWR sky130_fd_sc_hd__fill_1
XFILLER_26_49 VGND VGND VPWR VPWR sky130_fd_sc_hd__decap_3
XFILLER_53_255 VGND VGND VPWR VPWR sky130_fd_sc_hd__decap_3
X_6966_ _6966_/CLK _6966_/D VGND VGND VPWR VPWR _6966_/Q sky130_fd_sc_hd__dfxtp_2
XPHY_EDGE_ROW_24_Right_24 VGND VGND VPWR VPWR sky130_fd_sc_hd__decap_3
XFILLER_42_15 VGND VGND VPWR VPWR sky130_fd_sc_hd__decap_3
X_6897_ _6965_/CLK _6897_/D VGND VGND VPWR VPWR _6897_/Q sky130_fd_sc_hd__dfxtp_2
XFILLER_21_152 VGND VGND VPWR VPWR sky130_fd_sc_hd__decap_3
XTAP_TAPCELL_ROW_101_1459 VGND VPWR sky130_fd_sc_hd__tapvpwrvgnd_1
XFILLER_21_196 VGND VGND VPWR VPWR sky130_fd_sc_hd__decap_3
XFILLER_107_202 VGND VGND VPWR VPWR sky130_fd_sc_hd__decap_3
XPHY_EDGE_ROW_33_Right_33 VGND VGND VPWR VPWR sky130_fd_sc_hd__decap_3
XFILLER_107_41 VGND VGND VPWR VPWR sky130_fd_sc_hd__decap_3
Xhold860 _7104_/Q VGND VGND VPWR VPWR _7104_/D sky130_fd_sc_hd__dlygate4sd3_1
Xhold871 _7107_/Q VGND VGND VPWR VPWR _7107_/D sky130_fd_sc_hd__dlygate4sd3_1
Xhold882 _7077_/Q VGND VGND VPWR VPWR _7077_/D sky130_fd_sc_hd__dlygate4sd3_1
XFILLER_107_63 VGND VGND VPWR VPWR sky130_fd_sc_hd__decap_3
XFILLER_115_290 VGND VGND VPWR VPWR sky130_fd_sc_hd__decap_3
XFILLER_67_12 VGND VGND VPWR VPWR sky130_fd_sc_hd__decap_3
XFILLER_88_141 VGND VGND VPWR VPWR sky130_fd_sc_hd__decap_3
Xhold893 _7078_/Q VGND VGND VPWR VPWR _7078_/D sky130_fd_sc_hd__dlygate4sd3_1
XFILLER_67_45 VGND VGND VPWR VPWR sky130_fd_sc_hd__decap_3
XFILLER_88_174 VGND VGND VPWR VPWR sky130_fd_sc_hd__decap_3
XTAP_TAPCELL_ROW_112_1599 VGND VPWR sky130_fd_sc_hd__tapvpwrvgnd_1
XFILLER_29_296 VGND VGND VPWR VPWR sky130_fd_sc_hd__decap_3
XPHY_EDGE_ROW_42_Right_42 VGND VGND VPWR VPWR sky130_fd_sc_hd__decap_3
XFILLER_17_447 VGND VGND VPWR VPWR sky130_fd_sc_hd__fill_1
XFILLER_17_458 VGND VGND VPWR VPWR sky130_fd_sc_hd__decap_3
XFILLER_83_66 VGND VGND VPWR VPWR sky130_fd_sc_hd__decap_3
XTAP_TAPCELL_ROW_67_1056 VGND VPWR sky130_fd_sc_hd__tapvpwrvgnd_1
XFILLER_32_417 VGND VGND VPWR VPWR sky130_fd_sc_hd__decap_3
XFILLER_44_299 VGND VGND VPWR VPWR sky130_fd_sc_hd__decap_3
XFILLER_72_597 VGND VGND VPWR VPWR sky130_fd_sc_hd__decap_3
XTAP_TAPCELL_ROW_80_1212 VGND VPWR sky130_fd_sc_hd__tapvpwrvgnd_1
XFILLER_12_141 VGND VGND VPWR VPWR sky130_fd_sc_hd__decap_3
XTAP_TAPCELL_ROW_30_607 VGND VPWR sky130_fd_sc_hd__tapvpwrvgnd_1
XFILLER_40_494 VGND VGND VPWR VPWR sky130_fd_sc_hd__fill_2
XFILLER_73_9 VGND VGND VPWR VPWR sky130_fd_sc_hd__decap_3
XFILLER_8_156 VGND VGND VPWR VPWR sky130_fd_sc_hd__fill_2
XFILLER_8_178 VGND VGND VPWR VPWR sky130_fd_sc_hd__fill_1
XPHY_EDGE_ROW_51_Right_51 VGND VGND VPWR VPWR sky130_fd_sc_hd__decap_3
XFILLER_9_679 VGND VGND VPWR VPWR sky130_fd_sc_hd__decap_3
XTAP_TAPCELL_ROW_10_375 VGND VPWR sky130_fd_sc_hd__tapvpwrvgnd_1
XFILLER_113_205 VGND VGND VPWR VPWR sky130_fd_sc_hd__decap_3
XTAP_TAPCELL_ROW_78_1185 VGND VPWR sky130_fd_sc_hd__tapvpwrvgnd_1
XFILLER_4_362 VGND VGND VPWR VPWR sky130_fd_sc_hd__fill_2
XFILLER_99_428 VGND VGND VPWR VPWR sky130_fd_sc_hd__decap_3
XFILLER_113_249 VGND VGND VPWR VPWR sky130_fd_sc_hd__decap_3
XTAP_TAPCELL_ROW_91_1341 VGND VPWR sky130_fd_sc_hd__tapvpwrvgnd_1
XFILLER_79_152 VGND VGND VPWR VPWR sky130_fd_sc_hd__decap_3
XFILLER_79_196 VGND VGND VPWR VPWR sky130_fd_sc_hd__decap_3
XFILLER_94_144 VGND VGND VPWR VPWR sky130_fd_sc_hd__decap_3
XFILLER_95_656 VGND VGND VPWR VPWR sky130_fd_sc_hd__decap_3
XFILLER_94_155 VGND VGND VPWR VPWR sky130_fd_sc_hd__fill_1
XTAP_TAPCELL_ROW_38_707 VGND VPWR sky130_fd_sc_hd__tapvpwrvgnd_1
XPHY_EDGE_ROW_60_Right_60 VGND VGND VPWR VPWR sky130_fd_sc_hd__decap_3
XFILLER_82_339 VGND VGND VPWR VPWR sky130_fd_sc_hd__decap_3
XFILLER_35_244 VGND VGND VPWR VPWR sky130_fd_sc_hd__decap_3
X_6820_ _6977_/CLK _6820_/D VGND VGND VPWR VPWR _6820_/Q sky130_fd_sc_hd__dfxtp_2
XFILLER_50_203 VGND VGND VPWR VPWR sky130_fd_sc_hd__decap_3
XFILLER_50_214 VGND VGND VPWR VPWR sky130_fd_sc_hd__fill_1
XFILLER_63_575 VGND VGND VPWR VPWR sky130_fd_sc_hd__fill_1
XTAP_TAPCELL_ROW_18_464 VGND VPWR sky130_fd_sc_hd__tapvpwrvgnd_1
XFILLER_16_480 VGND VGND VPWR VPWR sky130_fd_sc_hd__fill_1
XFILLER_50_236 VGND VGND VPWR VPWR sky130_fd_sc_hd__fill_2
XFILLER_50_247 VGND VGND VPWR VPWR sky130_fd_sc_hd__decap_3
X_6751_ _6972_/CLK _6751_/D VGND VGND VPWR VPWR _6751_/Q sky130_fd_sc_hd__dfxtp_2
X_6682_ _6682_/A VGND VGND VPWR VPWR _6682_/Y sky130_fd_sc_hd__inv_2
X_3894_ _3728_/Y _3891_/X _3893_/X _3733_/X VGND VGND VPWR VPWR _3894_/X sky130_fd_sc_hd__a22o_2
XFILLER_12_18 VGND VGND VPWR VPWR sky130_fd_sc_hd__decap_3
X_5633_ _5633_/A _5633_/B VGND VGND VPWR VPWR _7012_/D sky130_fd_sc_hd__nor2_2
XFILLER_12_29 VGND VGND VPWR VPWR sky130_fd_sc_hd__decap_3
X_5564_ hold962/X _4909_/A _4751_/B VGND VGND VPWR VPWR _7052_/D sky130_fd_sc_hd__a21bo_2
X_7303_ _7369_/CLK _7303_/D _6583_/Y VGND VGND VPWR VPWR _7303_/Q sky130_fd_sc_hd__dfrtp_2
X_4515_ _4515_/A0 _7290_/Q _4534_/S VGND VGND VPWR VPWR _7322_/D sky130_fd_sc_hd__mux2_2
XPHY_EDGE_ROW_103_Right_103 VGND VGND VPWR VPWR sky130_fd_sc_hd__decap_3
X_7234_ _7267_/CLK _7234_/D _6514_/Y VGND VGND VPWR VPWR _7234_/Q sky130_fd_sc_hd__dfrtp_2
X_4446_ _4446_/A _4814_/B VGND VGND VPWR VPWR _4447_/B sky130_fd_sc_hd__nor2_2
X_7165_ _7356_/CLK _7165_/D _6445_/Y VGND VGND VPWR VPWR _7165_/Q sky130_fd_sc_hd__dfrtp_2
X_4377_ _4620_/C _4375_/X _4376_/X VGND VGND VPWR VPWR _4377_/Y sky130_fd_sc_hd__o21ai_2
X_3328_ _3328_/A _3328_/B VGND VGND VPWR VPWR _3340_/C sky130_fd_sc_hd__nor2_2
XPHY_EDGE_ROW_13_Left_130 VGND VGND VPWR VPWR sky130_fd_sc_hd__decap_3
XFILLER_112_282 VGND VGND VPWR VPWR sky130_fd_sc_hd__decap_3
XFILLER_37_15 VGND VGND VPWR VPWR sky130_fd_sc_hd__decap_3
XFILLER_58_347 VGND VGND VPWR VPWR sky130_fd_sc_hd__decap_3
XFILLER_85_122 VGND VGND VPWR VPWR sky130_fd_sc_hd__decap_3
XFILLER_86_645 VGND VGND VPWR VPWR sky130_fd_sc_hd__decap_3
X_7096_ clkload7/A _7096_/D _6376_/Y VGND VGND VPWR VPWR _7096_/Q sky130_fd_sc_hd__dfrtp_2
XFILLER_98_494 VGND VGND VPWR VPWR sky130_fd_sc_hd__decap_3
XFILLER_100_455 VGND VGND VPWR VPWR sky130_fd_sc_hd__decap_3
XFILLER_100_477 VGND VGND VPWR VPWR sky130_fd_sc_hd__decap_3
XFILLER_85_155 VGND VGND VPWR VPWR sky130_fd_sc_hd__decap_3
XFILLER_86_689 VGND VGND VPWR VPWR sky130_fd_sc_hd__decap_3
XFILLER_26_200 VGND VGND VPWR VPWR sky130_fd_sc_hd__decap_3
XFILLER_54_531 VGND VGND VPWR VPWR sky130_fd_sc_hd__fill_1
XFILLER_26_233 VGND VGND VPWR VPWR sky130_fd_sc_hd__decap_3
XFILLER_26_277 VGND VGND VPWR VPWR sky130_fd_sc_hd__decap_3
XFILLER_54_586 VGND VGND VPWR VPWR sky130_fd_sc_hd__fill_2
XFILLER_81_361 VGND VGND VPWR VPWR sky130_fd_sc_hd__decap_3
XFILLER_41_225 VGND VGND VPWR VPWR sky130_fd_sc_hd__decap_3
XFILLER_53_69 VGND VGND VPWR VPWR sky130_fd_sc_hd__decap_3
X_6949_ _6972_/CLK _6949_/D VGND VGND VPWR VPWR _6949_/Q sky130_fd_sc_hd__dfxtp_2
XFILLER_41_258 VGND VGND VPWR VPWR sky130_fd_sc_hd__decap_3
XFILLER_10_645 VGND VGND VPWR VPWR sky130_fd_sc_hd__fill_2
XFILLER_108_533 VGND VGND VPWR VPWR sky130_fd_sc_hd__decap_3
XFILLER_5_148 VGND VGND VPWR VPWR sky130_fd_sc_hd__decap_3
XTAP_TAPCELL_ROW_114_1617 VGND VPWR sky130_fd_sc_hd__tapvpwrvgnd_1
XFILLER_78_11 VGND VGND VPWR VPWR sky130_fd_sc_hd__decap_3
XFILLER_78_44 VGND VGND VPWR VPWR sky130_fd_sc_hd__decap_3
XFILLER_96_409 VGND VGND VPWR VPWR sky130_fd_sc_hd__decap_3
Xhold690 _6961_/Q VGND VGND VPWR VPWR _6961_/D sky130_fd_sc_hd__dlygate4sd3_1
XFILLER_103_260 VGND VGND VPWR VPWR sky130_fd_sc_hd__decap_3
XFILLER_77_612 VGND VGND VPWR VPWR sky130_fd_sc_hd__decap_3
XFILLER_78_88 VGND VGND VPWR VPWR sky130_fd_sc_hd__decap_3
XFILLER_1_387 VGND VGND VPWR VPWR sky130_fd_sc_hd__decap_3
XFILLER_64_306 VGND VGND VPWR VPWR sky130_fd_sc_hd__fill_2
XFILLER_76_144 VGND VGND VPWR VPWR sky130_fd_sc_hd__decap_3
XFILLER_94_21 VGND VGND VPWR VPWR sky130_fd_sc_hd__fill_2
XFILLER_92_637 VGND VGND VPWR VPWR sky130_fd_sc_hd__decap_3
XFILLER_92_648 VGND VGND VPWR VPWR sky130_fd_sc_hd__decap_3
XFILLER_94_76 VGND VGND VPWR VPWR sky130_fd_sc_hd__decap_3
XFILLER_17_222 VGND VGND VPWR VPWR sky130_fd_sc_hd__fill_2
XFILLER_17_255 VGND VGND VPWR VPWR sky130_fd_sc_hd__decap_3
XFILLER_91_158 VGND VGND VPWR VPWR sky130_fd_sc_hd__decap_3
XFILLER_32_203 VGND VGND VPWR VPWR sky130_fd_sc_hd__decap_3
XFILLER_45_575 VGND VGND VPWR VPWR sky130_fd_sc_hd__fill_1
XFILLER_32_247 VGND VGND VPWR VPWR sky130_fd_sc_hd__decap_3
XFILLER_72_394 VGND VGND VPWR VPWR sky130_fd_sc_hd__decap_3
XTAP_TAPCELL_ROW_15_434 VGND VPWR sky130_fd_sc_hd__tapvpwrvgnd_1
XFILLER_60_578 VGND VGND VPWR VPWR sky130_fd_sc_hd__fill_1
XFILLER_60_589 VGND VGND VPWR VPWR sky130_fd_sc_hd__decap_3
XTAP_TAPCELL_ROW_43_765 VGND VPWR sky130_fd_sc_hd__tapvpwrvgnd_1
XFILLER_9_421 VGND VGND VPWR VPWR sky130_fd_sc_hd__decap_3
XFILLER_71_6 VGND VGND VPWR VPWR sky130_fd_sc_hd__decap_3
XFILLER_5_682 VGND VGND VPWR VPWR sky130_fd_sc_hd__decap_3
X_5280_ _5280_/A0 _5121_/X _5292_/S VGND VGND VPWR VPWR _7190_/D sky130_fd_sc_hd__mux2_2
X_4300_ _7288_/Q _4530_/S VGND VGND VPWR VPWR _4300_/X sky130_fd_sc_hd__and2_2
XFILLER_99_236 VGND VGND VPWR VPWR sky130_fd_sc_hd__decap_3
XFILLER_114_569 VGND VGND VPWR VPWR sky130_fd_sc_hd__decap_3
XFILLER_4_181 VGND VGND VPWR VPWR sky130_fd_sc_hd__decap_3
XFILLER_4_41 VGND VGND VPWR VPWR sky130_fd_sc_hd__decap_3
X_4231_ _7040_/Q _4517_/S _4346_/B1 _7387_/Q _4230_/X VGND VGND VPWR VPWR _4231_/X
+ sky130_fd_sc_hd__a221o_2
XFILLER_4_74 VGND VGND VPWR VPWR sky130_fd_sc_hd__decap_3
XFILLER_4_85 VGND VGND VPWR VPWR sky130_fd_sc_hd__decap_3
XFILLER_67_111 VGND VGND VPWR VPWR sky130_fd_sc_hd__fill_1
XFILLER_68_634 VGND VGND VPWR VPWR sky130_fd_sc_hd__decap_3
XFILLER_68_645 VGND VGND VPWR VPWR sky130_fd_sc_hd__decap_3
XFILLER_95_431 VGND VGND VPWR VPWR sky130_fd_sc_hd__decap_3
X_4162_ _7137_/Q _4348_/B1 _4161_/X VGND VGND VPWR VPWR _4203_/A sky130_fd_sc_hd__a21o_2
XFILLER_68_678 VGND VGND VPWR VPWR sky130_fd_sc_hd__decap_3
XFILLER_95_464 VGND VGND VPWR VPWR sky130_fd_sc_hd__decap_3
X_4093_ _4394_/A _4394_/B _4092_/X VGND VGND VPWR VPWR _4210_/B sky130_fd_sc_hd__or3b_2
XFILLER_82_103 VGND VGND VPWR VPWR sky130_fd_sc_hd__decap_3
XFILLER_83_659 VGND VGND VPWR VPWR sky130_fd_sc_hd__fill_1
XFILLER_82_136 VGND VGND VPWR VPWR sky130_fd_sc_hd__decap_3
XFILLER_63_361 VGND VGND VPWR VPWR sky130_fd_sc_hd__decap_3
XFILLER_91_670 VGND VGND VPWR VPWR sky130_fd_sc_hd__fill_2
XFILLER_51_556 VGND VGND VPWR VPWR sky130_fd_sc_hd__decap_3
Xplace372 _3469_/A VGND VGND VPWR VPWR _4799_/A sky130_fd_sc_hd__buf_2
Xplace361 _4265_/B VGND VGND VPWR VPWR _4432_/A2 sky130_fd_sc_hd__buf_2
Xplace350 _3417_/X VGND VGND VPWR VPWR _4321_/A2 sky130_fd_sc_hd__buf_2
X_6803_ _7005_/CLK _6803_/D VGND VGND VPWR VPWR _6803_/Q sky130_fd_sc_hd__dfxtp_2
X_4995_ _4811_/C _4987_/Y _4993_/X _4994_/X VGND VGND VPWR VPWR _5657_/D sky130_fd_sc_hd__a211o_2
XFILLER_51_589 VGND VGND VPWR VPWR sky130_fd_sc_hd__decap_3
Xplace383 _3334_/Y VGND VGND VPWR VPWR _3339_/C1 sky130_fd_sc_hd__buf_2
Xplace394 _5350_/S VGND VGND VPWR VPWR _5327_/S sky130_fd_sc_hd__buf_2
X_6734_ _6966_/CLK _6734_/D VGND VGND VPWR VPWR _6734_/Q sky130_fd_sc_hd__dfxtp_2
X_6665_ _6670_/A VGND VGND VPWR VPWR _6665_/Y sky130_fd_sc_hd__inv_2
X_3877_ _6906_/Q _3879_/A2 _3878_/A2 _6850_/Q _3876_/X VGND VGND VPWR VPWR _3877_/X
+ sky130_fd_sc_hd__a221o_2
X_6596_ _6599_/A VGND VGND VPWR VPWR _6596_/Y sky130_fd_sc_hd__inv_2
XFILLER_105_503 VGND VGND VPWR VPWR sky130_fd_sc_hd__fill_1
XFILLER_105_514 VGND VGND VPWR VPWR sky130_fd_sc_hd__decap_3
XFILLER_2_118 VGND VGND VPWR VPWR sky130_fd_sc_hd__decap_3
XFILLER_105_558 VGND VGND VPWR VPWR sky130_fd_sc_hd__fill_2
XFILLER_3_9 VGND VGND VPWR VPWR sky130_fd_sc_hd__decap_3
XFILLER_78_409 VGND VGND VPWR VPWR sky130_fd_sc_hd__decap_3
X_7217_ _7322_/CLK _7217_/D _6497_/Y VGND VGND VPWR VPWR _7217_/Q sky130_fd_sc_hd__dfrtp_2
X_4429_ _7303_/Q _4488_/S _4429_/B1 _7367_/Q _4429_/C1 VGND VGND VPWR VPWR _4429_/X
+ sky130_fd_sc_hd__a221o_2
XFILLER_48_25 VGND VGND VPWR VPWR sky130_fd_sc_hd__decap_3
XFILLER_59_601 VGND VGND VPWR VPWR sky130_fd_sc_hd__decap_3
XFILLER_59_623 VGND VGND VPWR VPWR sky130_fd_sc_hd__decap_3
XFILLER_113_591 VGND VGND VPWR VPWR sky130_fd_sc_hd__decap_3
XFILLER_48_58 VGND VGND VPWR VPWR sky130_fd_sc_hd__fill_2
XFILLER_58_100 VGND VGND VPWR VPWR sky130_fd_sc_hd__decap_3
XFILLER_58_122 VGND VGND VPWR VPWR sky130_fd_sc_hd__decap_3
XFILLER_59_656 VGND VGND VPWR VPWR sky130_fd_sc_hd__decap_3
X_7148_ _7374_/CLK _7148_/D _6428_/Y VGND VGND VPWR VPWR _7148_/Q sky130_fd_sc_hd__dfrtp_2
XFILLER_58_144 VGND VGND VPWR VPWR sky130_fd_sc_hd__decap_3
XFILLER_74_604 VGND VGND VPWR VPWR sky130_fd_sc_hd__decap_3
X_7079_ _7266_/CLK _7079_/D _6359_/Y VGND VGND VPWR VPWR _7079_/Q sky130_fd_sc_hd__dfrtp_2
XFILLER_27_520 VGND VGND VPWR VPWR sky130_fd_sc_hd__decap_3
XFILLER_74_648 VGND VGND VPWR VPWR sky130_fd_sc_hd__fill_1
XFILLER_100_296 VGND VGND VPWR VPWR sky130_fd_sc_hd__fill_1
XFILLER_104_75 VGND VGND VPWR VPWR sky130_fd_sc_hd__decap_3
XFILLER_27_553 VGND VGND VPWR VPWR sky130_fd_sc_hd__decap_3
XFILLER_64_24 VGND VGND VPWR VPWR sky130_fd_sc_hd__decap_3
XFILLER_64_35 VGND VGND VPWR VPWR sky130_fd_sc_hd__decap_3
XFILLER_14_203 VGND VGND VPWR VPWR sky130_fd_sc_hd__decap_3
XFILLER_27_564 VGND VGND VPWR VPWR sky130_fd_sc_hd__decap_3
XFILLER_54_361 VGND VGND VPWR VPWR sky130_fd_sc_hd__decap_3
XFILLER_64_68 VGND VGND VPWR VPWR sky130_fd_sc_hd__decap_3
XFILLER_73_169 VGND VGND VPWR VPWR sky130_fd_sc_hd__decap_3
XFILLER_82_681 VGND VGND VPWR VPWR sky130_fd_sc_hd__decap_3
XTAP_TAPCELL_ROW_64_1015 VGND VPWR sky130_fd_sc_hd__tapvpwrvgnd_1
XFILLER_14_236 VGND VGND VPWR VPWR sky130_fd_sc_hd__decap_3
XFILLER_42_556 VGND VGND VPWR VPWR sky130_fd_sc_hd__decap_3
XFILLER_81_180 VGND VGND VPWR VPWR sky130_fd_sc_hd__decap_3
XFILLER_14_269 VGND VGND VPWR VPWR sky130_fd_sc_hd__decap_3
XFILLER_42_589 VGND VGND VPWR VPWR sky130_fd_sc_hd__decap_3
XFILLER_80_23 VGND VGND VPWR VPWR sky130_fd_sc_hd__decap_3
Xfanout40 _6547_/A VGND VGND VPWR VPWR _6548_/A sky130_fd_sc_hd__buf_2
XFILLER_80_56 VGND VGND VPWR VPWR sky130_fd_sc_hd__decap_3
Xfanout51 reset VGND VGND VPWR VPWR fanout51/X sky130_fd_sc_hd__clkdlybuf4s25_1
Xfanout62 fanout72/X VGND VGND VPWR VPWR _6587_/A sky130_fd_sc_hd__clkdlybuf4s25_1
Xfanout73 reset VGND VGND VPWR VPWR _6280_/A sky130_fd_sc_hd__buf_1
XTAP_TAPCELL_ROW_40_735 VGND VPWR sky130_fd_sc_hd__tapvpwrvgnd_1
XFILLER_10_431 VGND VGND VPWR VPWR sky130_fd_sc_hd__decap_3
XFILLER_13_50 VGND VGND VPWR VPWR sky130_fd_sc_hd__decap_3
XFILLER_10_475 VGND VGND VPWR VPWR sky130_fd_sc_hd__fill_1
XFILLER_108_352 VGND VGND VPWR VPWR sky130_fd_sc_hd__decap_3
XFILLER_89_32 VGND VGND VPWR VPWR sky130_fd_sc_hd__decap_3
XTAP_TAPCELL_ROW_20_492 VGND VPWR sky130_fd_sc_hd__tapvpwrvgnd_1
XFILLER_89_54 VGND VGND VPWR VPWR sky130_fd_sc_hd__fill_2
XFILLER_2_630 VGND VGND VPWR VPWR sky130_fd_sc_hd__decap_3
XFILLER_69_409 VGND VGND VPWR VPWR sky130_fd_sc_hd__decap_3
XTAP_TAPCELL_ROW_75_1155 VGND VPWR sky130_fd_sc_hd__tapvpwrvgnd_1
XFILLER_111_517 VGND VGND VPWR VPWR sky130_fd_sc_hd__decap_3
XFILLER_1_140 VGND VGND VPWR VPWR sky130_fd_sc_hd__decap_3
XFILLER_2_663 VGND VGND VPWR VPWR sky130_fd_sc_hd__decap_3
XFILLER_36_9 VGND VGND VPWR VPWR sky130_fd_sc_hd__decap_3
XFILLER_77_431 VGND VGND VPWR VPWR sky130_fd_sc_hd__decap_3
XFILLER_89_291 VGND VGND VPWR VPWR sky130_fd_sc_hd__decap_3
XFILLER_49_144 VGND VGND VPWR VPWR sky130_fd_sc_hd__decap_3
XFILLER_77_464 VGND VGND VPWR VPWR sky130_fd_sc_hd__decap_3
XFILLER_37_328 VGND VGND VPWR VPWR sky130_fd_sc_hd__decap_3
XFILLER_49_177 VGND VGND VPWR VPWR sky130_fd_sc_hd__decap_3
XFILLER_64_103 VGND VGND VPWR VPWR sky130_fd_sc_hd__decap_3
XFILLER_65_626 VGND VGND VPWR VPWR sky130_fd_sc_hd__decap_3
XTAP_TAPCELL_ROW_48_824 VGND VPWR sky130_fd_sc_hd__tapvpwrvgnd_1
XFILLER_65_659 VGND VGND VPWR VPWR sky130_fd_sc_hd__decap_3
XFILLER_52_309 VGND VGND VPWR VPWR sky130_fd_sc_hd__decap_3
XFILLER_92_489 VGND VGND VPWR VPWR sky130_fd_sc_hd__decap_3
XFILLER_18_597 VGND VGND VPWR VPWR sky130_fd_sc_hd__fill_1
XFILLER_72_191 VGND VGND VPWR VPWR sky130_fd_sc_hd__decap_3
XTAP_TAPCELL_ROW_86_1284 VGND VPWR sky130_fd_sc_hd__tapvpwrvgnd_1
XTAP_TAPCELL_ROW_28_592 VGND VPWR sky130_fd_sc_hd__tapvpwrvgnd_1
X_4780_ _4779_/X _4447_/B _4795_/A VGND VGND VPWR VPWR _4780_/Y sky130_fd_sc_hd__a21oi_2
X_3800_ _6861_/Q _3891_/A2 _3878_/B1 _6901_/Q _3799_/X VGND VGND VPWR VPWR _3800_/X
+ sky130_fd_sc_hd__a221o_2
XFILLER_20_206 VGND VGND VPWR VPWR sky130_fd_sc_hd__fill_2
XFILLER_60_386 VGND VGND VPWR VPWR sky130_fd_sc_hd__decap_3
X_3731_ _6758_/Q _5660_/B _3869_/B1 _6770_/Q VGND VGND VPWR VPWR _3731_/X sky130_fd_sc_hd__a22o_2
Xclkload10 _7279_/CLK VGND VGND VPWR VPWR clkload10/X sky130_fd_sc_hd__clkbuf_1
X_6450_ _6611_/A VGND VGND VPWR VPWR _6450_/Y sky130_fd_sc_hd__inv_2
Xclkload21 _7358_/CLK VGND VGND VPWR VPWR clkload21/X sky130_fd_sc_hd__clkbuf_8
Xclkload32 _7230_/CLK VGND VGND VPWR VPWR clkload32/X sky130_fd_sc_hd__clkbuf_1
X_6381_ _6539_/A VGND VGND VPWR VPWR _6381_/Y sky130_fd_sc_hd__inv_2
X_3593_ _3620_/A _4292_/B _3592_/X VGND VGND VPWR VPWR _3594_/B sky130_fd_sc_hd__a21o_2
XFILLER_114_300 VGND VGND VPWR VPWR sky130_fd_sc_hd__decap_3
XFILLER_102_528 VGND VGND VPWR VPWR sky130_fd_sc_hd__decap_3
XFILLER_87_206 VGND VGND VPWR VPWR sky130_fd_sc_hd__decap_3
XFILLER_114_399 VGND VGND VPWR VPWR sky130_fd_sc_hd__fill_1
XFILLER_68_431 VGND VGND VPWR VPWR sky130_fd_sc_hd__decap_3
X_7002_ _7341_/CLK _7002_/D _6282_/Y VGND VGND VPWR VPWR _7002_/Q sky130_fd_sc_hd__dfrtp_2
X_5194_ _5194_/A _5194_/B VGND VGND VPWR VPWR _7231_/D sky130_fd_sc_hd__and2_2
X_4214_ _7228_/Q _3377_/X _3366_/X _7164_/Q _4213_/X VGND VGND VPWR VPWR _4214_/X
+ sky130_fd_sc_hd__a221o_2
XFILLER_28_306 VGND VGND VPWR VPWR sky130_fd_sc_hd__fill_2
XFILLER_56_615 VGND VGND VPWR VPWR sky130_fd_sc_hd__decap_3
XFILLER_68_464 VGND VGND VPWR VPWR sky130_fd_sc_hd__fill_2
X_4145_ _7298_/Q _4499_/S _4144_/X _4419_/C1 VGND VGND VPWR VPWR _4145_/X sky130_fd_sc_hd__a211o_2
XFILLER_110_583 VGND VGND VPWR VPWR sky130_fd_sc_hd__decap_3
XFILLER_55_103 VGND VGND VPWR VPWR sky130_fd_sc_hd__decap_3
XFILLER_55_125 VGND VGND VPWR VPWR sky130_fd_sc_hd__fill_1
XFILLER_56_648 VGND VGND VPWR VPWR sky130_fd_sc_hd__decap_3
XFILLER_68_486 VGND VGND VPWR VPWR sky130_fd_sc_hd__decap_3
XFILLER_55_158 VGND VGND VPWR VPWR sky130_fd_sc_hd__decap_3
XFILLER_83_445 VGND VGND VPWR VPWR sky130_fd_sc_hd__decap_3
X_4076_ _7147_/Q _4434_/B1 _4436_/B1 _7179_/Q VGND VGND VPWR VPWR _4076_/X sky130_fd_sc_hd__a22o_2
XFILLER_55_169 VGND VGND VPWR VPWR sky130_fd_sc_hd__decap_3
XFILLER_64_681 VGND VGND VPWR VPWR sky130_fd_sc_hd__decap_3
XFILLER_71_629 VGND VGND VPWR VPWR sky130_fd_sc_hd__decap_3
XFILLER_51_320 VGND VGND VPWR VPWR sky130_fd_sc_hd__decap_3
XFILLER_70_128 VGND VGND VPWR VPWR sky130_fd_sc_hd__decap_3
XFILLER_51_353 VGND VGND VPWR VPWR sky130_fd_sc_hd__decap_3
XFILLER_11_217 VGND VGND VPWR VPWR sky130_fd_sc_hd__decap_3
XFILLER_11_228 VGND VGND VPWR VPWR sky130_fd_sc_hd__decap_3
X_4978_ _5092_/C _4973_/X _4975_/Y _6993_/D _4997_/A1 VGND VGND VPWR VPWR _4978_/X
+ sky130_fd_sc_hd__a32o_2
Xclkload4 clkload4/A VGND VGND VPWR VPWR clkload4/X sky130_fd_sc_hd__clkbuf_8
X_6717_ _7406_/CLK _6717_/D VGND VGND VPWR VPWR _6717_/Q sky130_fd_sc_hd__dfxtp_2
XFILLER_109_116 VGND VGND VPWR VPWR sky130_fd_sc_hd__fill_1
XFILLER_109_138 VGND VGND VPWR VPWR sky130_fd_sc_hd__decap_3
X_6648_ _6682_/A VGND VGND VPWR VPWR _6648_/Y sky130_fd_sc_hd__inv_2
XFILLER_50_59 VGND VGND VPWR VPWR sky130_fd_sc_hd__decap_3
XFILLER_3_405 VGND VGND VPWR VPWR sky130_fd_sc_hd__decap_3
X_6579_ _6611_/A VGND VGND VPWR VPWR _6579_/Y sky130_fd_sc_hd__inv_2
XFILLER_105_333 VGND VGND VPWR VPWR sky130_fd_sc_hd__decap_3
XFILLER_3_438 VGND VGND VPWR VPWR sky130_fd_sc_hd__decap_3
XFILLER_3_449 VGND VGND VPWR VPWR sky130_fd_sc_hd__fill_1
XFILLER_59_57 VGND VGND VPWR VPWR sky130_fd_sc_hd__decap_3
XFILLER_78_206 VGND VGND VPWR VPWR sky130_fd_sc_hd__fill_1
XFILLER_78_228 VGND VGND VPWR VPWR sky130_fd_sc_hd__decap_3
XFILLER_115_41 VGND VGND VPWR VPWR sky130_fd_sc_hd__decap_3
XFILLER_115_63 VGND VGND VPWR VPWR sky130_fd_sc_hd__decap_3
XFILLER_59_442 VGND VGND VPWR VPWR sky130_fd_sc_hd__decap_3
XFILLER_101_561 VGND VGND VPWR VPWR sky130_fd_sc_hd__fill_2
XFILLER_101_583 VGND VGND VPWR VPWR sky130_fd_sc_hd__decap_3
XFILLER_115_96 VGND VGND VPWR VPWR sky130_fd_sc_hd__decap_3
XFILLER_47_626 VGND VGND VPWR VPWR sky130_fd_sc_hd__decap_3
XFILLER_74_412 VGND VGND VPWR VPWR sky130_fd_sc_hd__decap_3
XTAP_TAPCELL_ROW_70_1096 VGND VPWR sky130_fd_sc_hd__tapvpwrvgnd_1
XFILLER_46_125 VGND VGND VPWR VPWR sky130_fd_sc_hd__fill_1
XFILLER_47_659 VGND VGND VPWR VPWR sky130_fd_sc_hd__decap_3
XFILLER_75_78 VGND VGND VPWR VPWR sky130_fd_sc_hd__decap_3
XFILLER_34_309 VGND VGND VPWR VPWR sky130_fd_sc_hd__decap_3
XFILLER_61_106 VGND VGND VPWR VPWR sky130_fd_sc_hd__decap_3
XFILLER_62_629 VGND VGND VPWR VPWR sky130_fd_sc_hd__decap_3
XFILLER_74_489 VGND VGND VPWR VPWR sky130_fd_sc_hd__decap_3
XFILLER_27_383 VGND VGND VPWR VPWR sky130_fd_sc_hd__decap_3
XFILLER_42_320 VGND VGND VPWR VPWR sky130_fd_sc_hd__decap_3
XFILLER_54_180 VGND VGND VPWR VPWR sky130_fd_sc_hd__decap_3
XFILLER_15_556 VGND VGND VPWR VPWR sky130_fd_sc_hd__decap_3
XFILLER_15_567 VGND VGND VPWR VPWR sky130_fd_sc_hd__decap_3
XFILLER_42_353 VGND VGND VPWR VPWR sky130_fd_sc_hd__decap_3
XTAP_TAPCELL_ROW_25_551 VGND VPWR sky130_fd_sc_hd__tapvpwrvgnd_1
XFILLER_42_375 VGND VGND VPWR VPWR sky130_fd_sc_hd__decap_3
XFILLER_91_77 VGND VGND VPWR VPWR sky130_fd_sc_hd__fill_1
XTAP_TAPCELL_ROW_53_893 VGND VPWR sky130_fd_sc_hd__tapvpwrvgnd_1
XTAP_TAPCELL_ROW_53_882 VGND VPWR sky130_fd_sc_hd__tapvpwrvgnd_1
XFILLER_109_650 VGND VGND VPWR VPWR sky130_fd_sc_hd__decap_3
XFILLER_116_609 VGND VGND VPWR VPWR sky130_fd_sc_hd__decap_3
XFILLER_6_232 VGND VGND VPWR VPWR sky130_fd_sc_hd__decap_3
XFILLER_115_108 VGND VGND VPWR VPWR sky130_fd_sc_hd__decap_3
XFILLER_115_119 VGND VGND VPWR VPWR sky130_fd_sc_hd__decap_3
XFILLER_40_81 VGND VGND VPWR VPWR sky130_fd_sc_hd__decap_3
XFILLER_6_298 VGND VGND VPWR VPWR sky130_fd_sc_hd__fill_2
XFILLER_97_526 VGND VGND VPWR VPWR sky130_fd_sc_hd__fill_1
XFILLER_111_325 VGND VGND VPWR VPWR sky130_fd_sc_hd__decap_3
XFILLER_2_493 VGND VGND VPWR VPWR sky130_fd_sc_hd__fill_2
XFILLER_69_228 VGND VGND VPWR VPWR sky130_fd_sc_hd__decap_3
XFILLER_97_559 VGND VGND VPWR VPWR sky130_fd_sc_hd__fill_1
XFILLER_111_358 VGND VGND VPWR VPWR sky130_fd_sc_hd__decap_3
XFILLER_1_20 VGND VGND VPWR VPWR sky130_fd_sc_hd__decap_3
XFILLER_38_615 VGND VGND VPWR VPWR sky130_fd_sc_hd__decap_3
XTAP_TAPCELL_ROW_88_1313 VGND VPWR sky130_fd_sc_hd__tapvpwrvgnd_1
XTAP_TAPCELL_ROW_88_1302 VGND VPWR sky130_fd_sc_hd__tapvpwrvgnd_1
XFILLER_1_53 VGND VGND VPWR VPWR sky130_fd_sc_hd__decap_3
XFILLER_77_294 VGND VGND VPWR VPWR sky130_fd_sc_hd__decap_3
XFILLER_1_75 VGND VGND VPWR VPWR sky130_fd_sc_hd__decap_3
XFILLER_37_158 VGND VGND VPWR VPWR sky130_fd_sc_hd__decap_3
XFILLER_37_169 VGND VGND VPWR VPWR sky130_fd_sc_hd__decap_3
XFILLER_53_607 VGND VGND VPWR VPWR sky130_fd_sc_hd__decap_3
XFILLER_53_629 VGND VGND VPWR VPWR sky130_fd_sc_hd__decap_3
XFILLER_65_478 VGND VGND VPWR VPWR sky130_fd_sc_hd__decap_3
XFILLER_80_404 VGND VGND VPWR VPWR sky130_fd_sc_hd__decap_3
XFILLER_92_253 VGND VGND VPWR VPWR sky130_fd_sc_hd__decap_3
XFILLER_18_383 VGND VGND VPWR VPWR sky130_fd_sc_hd__decap_3
XFILLER_46_681 VGND VGND VPWR VPWR sky130_fd_sc_hd__decap_3
XFILLER_80_426 VGND VGND VPWR VPWR sky130_fd_sc_hd__fill_1
XFILLER_92_297 VGND VGND VPWR VPWR sky130_fd_sc_hd__fill_2
X_4901_ _4901_/A0 _4899_/X _5028_/S VGND VGND VPWR VPWR _7268_/D sky130_fd_sc_hd__mux2_2
XFILLER_61_662 VGND VGND VPWR VPWR sky130_fd_sc_hd__decap_3
XFILLER_61_673 VGND VGND VPWR VPWR sky130_fd_sc_hd__decap_3
XFILLER_60_150 VGND VGND VPWR VPWR sky130_fd_sc_hd__decap_3
XFILLER_60_183 VGND VGND VPWR VPWR sky130_fd_sc_hd__fill_1
X_4832_ _4832_/A _5657_/A VGND VGND VPWR VPWR _4832_/X sky130_fd_sc_hd__or2_2
X_4763_ _4762_/A _4762_/B _4948_/A VGND VGND VPWR VPWR _4763_/X sky130_fd_sc_hd__a21o_2
X_6502_ _6567_/A VGND VGND VPWR VPWR _6502_/Y sky130_fd_sc_hd__inv_2
X_4694_ _7008_/Q _4728_/A VGND VGND VPWR VPWR _4694_/Y sky130_fd_sc_hd__nor2_2
X_3714_ _3735_/A _3741_/B _3746_/C VGND VGND VPWR VPWR _3714_/X sky130_fd_sc_hd__and3_2
XTAP_TAPCELL_ROW_99_1442 VGND VPWR sky130_fd_sc_hd__tapvpwrvgnd_1
X_6433_ _6562_/A VGND VGND VPWR VPWR _6433_/Y sky130_fd_sc_hd__inv_2
XFILLER_20_18 VGND VGND VPWR VPWR sky130_fd_sc_hd__decap_3
XFILLER_20_29 VGND VGND VPWR VPWR sky130_fd_sc_hd__decap_3
X_3645_ hold967/X _4466_/A _4664_/B VGND VGND VPWR VPWR _7406_/D sky130_fd_sc_hd__a21o_2
XFILLER_115_620 VGND VGND VPWR VPWR sky130_fd_sc_hd__decap_3
XFILLER_115_653 VGND VGND VPWR VPWR sky130_fd_sc_hd__decap_3
X_6364_ _6366_/A VGND VGND VPWR VPWR _6364_/Y sky130_fd_sc_hd__inv_2
X_3576_ _7252_/Q _3358_/X _4340_/A2 _7220_/Q _3575_/X VGND VGND VPWR VPWR _3591_/B
+ sky130_fd_sc_hd__a221oi_2
XFILLER_102_303 VGND VGND VPWR VPWR sky130_fd_sc_hd__decap_3
XFILLER_114_130 VGND VGND VPWR VPWR sky130_fd_sc_hd__decap_3
XFILLER_114_141 VGND VGND VPWR VPWR sky130_fd_sc_hd__decap_3
X_6295_ _6535_/A VGND VGND VPWR VPWR _6295_/Y sky130_fd_sc_hd__inv_2
X_5315_ _5315_/A0 _4878_/X _5327_/S VGND VGND VPWR VPWR _7173_/D sky130_fd_sc_hd__mux2_2
XFILLER_114_174 VGND VGND VPWR VPWR sky130_fd_sc_hd__decap_3
XFILLER_29_27 VGND VGND VPWR VPWR sky130_fd_sc_hd__decap_3
XFILLER_29_604 VGND VGND VPWR VPWR sky130_fd_sc_hd__fill_2
XFILLER_75_209 VGND VGND VPWR VPWR sky130_fd_sc_hd__decap_3
XPHY_EDGE_ROW_89_Right_89 VGND VGND VPWR VPWR sky130_fd_sc_hd__decap_3
XFILLER_28_103 VGND VGND VPWR VPWR sky130_fd_sc_hd__decap_3
XFILLER_96_570 VGND VGND VPWR VPWR sky130_fd_sc_hd__decap_3
XFILLER_96_592 VGND VGND VPWR VPWR sky130_fd_sc_hd__decap_3
X_5177_ _5177_/A _5182_/B VGND VGND VPWR VPWR _7239_/D sky130_fd_sc_hd__and2_2
XFILLER_28_147 VGND VGND VPWR VPWR sky130_fd_sc_hd__decap_3
XFILLER_56_434 VGND VGND VPWR VPWR sky130_fd_sc_hd__fill_1
X_4128_ _7331_/Q _3958_/S _4348_/B1 _7139_/Q VGND VGND VPWR VPWR _4128_/X sky130_fd_sc_hd__a22o_2
XFILLER_16_309 VGND VGND VPWR VPWR sky130_fd_sc_hd__fill_1
XFILLER_45_15 VGND VGND VPWR VPWR sky130_fd_sc_hd__decap_3
XFILLER_83_253 VGND VGND VPWR VPWR sky130_fd_sc_hd__decap_3
X_4059_ _7276_/Q _4437_/A2 _4056_/X _4058_/X VGND VGND VPWR VPWR _4059_/X sky130_fd_sc_hd__a211o_2
XFILLER_36_180 VGND VGND VPWR VPWR sky130_fd_sc_hd__decap_3
XFILLER_37_681 VGND VGND VPWR VPWR sky130_fd_sc_hd__fill_1
XFILLER_45_48 VGND VGND VPWR VPWR sky130_fd_sc_hd__decap_3
XFILLER_101_32 VGND VGND VPWR VPWR sky130_fd_sc_hd__decap_3
XFILLER_52_640 VGND VGND VPWR VPWR sky130_fd_sc_hd__decap_3
XFILLER_52_651 VGND VGND VPWR VPWR sky130_fd_sc_hd__decap_3
XFILLER_101_54 VGND VGND VPWR VPWR sky130_fd_sc_hd__fill_2
XFILLER_24_386 VGND VGND VPWR VPWR sky130_fd_sc_hd__decap_3
XFILLER_52_684 VGND VGND VPWR VPWR sky130_fd_sc_hd__decap_3
XFILLER_61_25 VGND VGND VPWR VPWR sky130_fd_sc_hd__decap_3
XTAP_TAPCELL_ROW_22_510 VGND VPWR sky130_fd_sc_hd__tapvpwrvgnd_1
XPHY_EDGE_ROW_98_Right_98 VGND VGND VPWR VPWR sky130_fd_sc_hd__decap_3
XFILLER_101_98 VGND VGND VPWR VPWR sky130_fd_sc_hd__decap_3
XTAP_TAPCELL_ROW_50_852 VGND VPWR sky130_fd_sc_hd__tapvpwrvgnd_1
XTAP_TAPCELL_ROW_22_521 VGND VPWR sky130_fd_sc_hd__tapvpwrvgnd_1
XFILLER_61_69 VGND VGND VPWR VPWR sky130_fd_sc_hd__decap_3
XFILLER_106_631 VGND VGND VPWR VPWR sky130_fd_sc_hd__decap_3
XFILLER_106_675 VGND VGND VPWR VPWR sky130_fd_sc_hd__decap_3
XFILLER_10_62 VGND VGND VPWR VPWR sky130_fd_sc_hd__decap_3
XTAP_TAPCELL_ROW_72_1114 VGND VPWR sky130_fd_sc_hd__tapvpwrvgnd_1
XPHY_EDGE_ROW_5_Left_122 VGND VGND VPWR VPWR sky130_fd_sc_hd__decap_3
XFILLER_3_279 VGND VGND VPWR VPWR sky130_fd_sc_hd__fill_1
XFILLER_79_559 VGND VGND VPWR VPWR sky130_fd_sc_hd__fill_1
XFILLER_86_55 VGND VGND VPWR VPWR sky130_fd_sc_hd__decap_3
XFILLER_59_261 VGND VGND VPWR VPWR sky130_fd_sc_hd__decap_3
XFILLER_86_88 VGND VGND VPWR VPWR sky130_fd_sc_hd__decap_3
XFILLER_19_147 VGND VGND VPWR VPWR sky130_fd_sc_hd__decap_3
XTAP_TAPCELL_ROW_58_952 VGND VPWR sky130_fd_sc_hd__tapvpwrvgnd_1
XFILLER_19_169 VGND VGND VPWR VPWR sky130_fd_sc_hd__decap_3
XFILLER_19_93 VGND VGND VPWR VPWR sky130_fd_sc_hd__decap_3
XFILLER_34_106 VGND VGND VPWR VPWR sky130_fd_sc_hd__decap_3
XFILLER_74_253 VGND VGND VPWR VPWR sky130_fd_sc_hd__decap_3
XFILLER_15_320 VGND VGND VPWR VPWR sky130_fd_sc_hd__decap_3
XFILLER_34_139 VGND VGND VPWR VPWR sky130_fd_sc_hd__fill_1
XFILLER_74_286 VGND VGND VPWR VPWR sky130_fd_sc_hd__fill_2
XFILLER_74_297 VGND VGND VPWR VPWR sky130_fd_sc_hd__decap_3
XFILLER_43_662 VGND VGND VPWR VPWR sky130_fd_sc_hd__decap_3
XTAP_TAPCELL_ROW_83_1243 VGND VPWR sky130_fd_sc_hd__tapvpwrvgnd_1
XFILLER_15_364 VGND VGND VPWR VPWR sky130_fd_sc_hd__decap_3
XFILLER_30_312 VGND VGND VPWR VPWR sky130_fd_sc_hd__decap_3
XFILLER_42_150 VGND VGND VPWR VPWR sky130_fd_sc_hd__decap_3
XFILLER_43_673 VGND VGND VPWR VPWR sky130_fd_sc_hd__decap_3
XFILLER_30_323 VGND VGND VPWR VPWR sky130_fd_sc_hd__decap_3
XFILLER_42_194 VGND VGND VPWR VPWR sky130_fd_sc_hd__fill_2
XFILLER_70_492 VGND VGND VPWR VPWR sky130_fd_sc_hd__fill_1
XFILLER_51_91 VGND VGND VPWR VPWR sky130_fd_sc_hd__decap_3
XFILLER_7_541 VGND VGND VPWR VPWR sky130_fd_sc_hd__decap_3
XFILLER_116_417 VGND VGND VPWR VPWR sky130_fd_sc_hd__decap_3
XFILLER_112_601 VGND VGND VPWR VPWR sky130_fd_sc_hd__decap_3
X_3361_ _6982_/Q _3386_/B VGND VGND VPWR VPWR _3376_/B sky130_fd_sc_hd__and2_2
XTAP_TAPCELL_ROW_94_1383 VGND VPWR sky130_fd_sc_hd__tapvpwrvgnd_1
XFILLER_111_111 VGND VGND VPWR VPWR sky130_fd_sc_hd__fill_1
XFILLER_112_634 VGND VGND VPWR VPWR sky130_fd_sc_hd__decap_3
XFILLER_32_3 VGND VGND VPWR VPWR sky130_fd_sc_hd__decap_3
X_5100_ _5100_/A _5100_/B VGND VGND VPWR VPWR _5100_/Y sky130_fd_sc_hd__xnor2_2
XFILLER_111_122 VGND VGND VPWR VPWR sky130_fd_sc_hd__decap_3
XFILLER_112_645 VGND VGND VPWR VPWR sky130_fd_sc_hd__decap_3
XFILLER_112_678 VGND VGND VPWR VPWR sky130_fd_sc_hd__decap_3
XFILLER_97_345 VGND VGND VPWR VPWR sky130_fd_sc_hd__decap_3
XFILLER_97_367 VGND VGND VPWR VPWR sky130_fd_sc_hd__decap_3
X_5031_ _5032_/A _5031_/B VGND VGND VPWR VPWR _5031_/X sky130_fd_sc_hd__xor2_2
XFILLER_111_188 VGND VGND VPWR VPWR sky130_fd_sc_hd__decap_3
XFILLER_78_581 VGND VGND VPWR VPWR sky130_fd_sc_hd__decap_3
Xhold1208 _7147_/Q VGND VGND VPWR VPWR _5371_/A0 sky130_fd_sc_hd__dlygate4sd3_1
XFILLER_65_220 VGND VGND VPWR VPWR sky130_fd_sc_hd__decap_3
XFILLER_65_231 VGND VGND VPWR VPWR sky130_fd_sc_hd__decap_3
XFILLER_78_592 VGND VGND VPWR VPWR sky130_fd_sc_hd__fill_2
XFILLER_93_540 VGND VGND VPWR VPWR sky130_fd_sc_hd__decap_3
XFILLER_26_607 VGND VGND VPWR VPWR sky130_fd_sc_hd__decap_3
XFILLER_38_467 VGND VGND VPWR VPWR sky130_fd_sc_hd__decap_3
XFILLER_38_489 VGND VGND VPWR VPWR sky130_fd_sc_hd__decap_3
XPHY_EDGE_ROW_69_Left_186 VGND VGND VPWR VPWR sky130_fd_sc_hd__decap_3
XFILLER_53_426 VGND VGND VPWR VPWR sky130_fd_sc_hd__decap_3
XFILLER_93_595 VGND VGND VPWR VPWR sky130_fd_sc_hd__decap_3
X_6982_ _7264_/CLK _6982_/D _6262_/Y VGND VGND VPWR VPWR _6982_/Q sky130_fd_sc_hd__dfrtp_2
XTAP_TAPCELL_ROW_0_249 VGND VPWR sky130_fd_sc_hd__tapvpwrvgnd_1
XTAP_TAPCELL_ROW_0_238 VGND VPWR sky130_fd_sc_hd__tapvpwrvgnd_1
XFILLER_15_18 VGND VGND VPWR VPWR sky130_fd_sc_hd__decap_3
XFILLER_18_180 VGND VGND VPWR VPWR sky130_fd_sc_hd__decap_3
XFILLER_80_267 VGND VGND VPWR VPWR sky130_fd_sc_hd__fill_2
XFILLER_33_150 VGND VGND VPWR VPWR sky130_fd_sc_hd__decap_3
XFILLER_33_172 VGND VGND VPWR VPWR sky130_fd_sc_hd__decap_3
XFILLER_40_109 VGND VGND VPWR VPWR sky130_fd_sc_hd__decap_3
XTAP_TAPCELL_ROW_36_679 VGND VPWR sky130_fd_sc_hd__tapvpwrvgnd_1
XFILLER_21_334 VGND VGND VPWR VPWR sky130_fd_sc_hd__fill_2
X_4815_ _4812_/Y _4813_/Y _4814_/Y _4779_/X VGND VGND VPWR VPWR _4815_/X sky130_fd_sc_hd__o211a_2
XFILLER_21_356 VGND VGND VPWR VPWR sky130_fd_sc_hd__decap_3
XTAP_TAPCELL_ROW_103_1490 VGND VPWR sky130_fd_sc_hd__tapvpwrvgnd_1
X_4746_ _4764_/B _4069_/B _4744_/Y _4745_/Y _4852_/A VGND VGND VPWR VPWR _4746_/X
+ sky130_fd_sc_hd__o32a_2
X_4677_ _6989_/Q _4677_/B VGND VGND VPWR VPWR _5036_/A sky130_fd_sc_hd__and2_2
XPHY_EDGE_ROW_78_Left_195 VGND VGND VPWR VPWR sky130_fd_sc_hd__decap_3
XFILLER_103_9 VGND VGND VPWR VPWR sky130_fd_sc_hd__decap_3
X_7396_ _7401_/CLK _7396_/D _6676_/Y VGND VGND VPWR VPWR _7396_/Q sky130_fd_sc_hd__dfrtp_2
X_6416_ _6608_/A VGND VGND VPWR VPWR _6416_/Y sky130_fd_sc_hd__inv_2
XFILLER_103_601 VGND VGND VPWR VPWR sky130_fd_sc_hd__decap_3
X_6347_ _6347_/A VGND VGND VPWR VPWR _6347_/Y sky130_fd_sc_hd__inv_2
XFILLER_102_100 VGND VGND VPWR VPWR sky130_fd_sc_hd__decap_3
XFILLER_88_312 VGND VGND VPWR VPWR sky130_fd_sc_hd__decap_3
XFILLER_88_334 VGND VGND VPWR VPWR sky130_fd_sc_hd__decap_3
X_3559_ _3553_/X _3557_/X _3558_/X _3590_/A VGND VGND VPWR VPWR _4295_/B sky130_fd_sc_hd__o211a_2
XTAP_TAPCELL_ROW_8_349 VGND VPWR sky130_fd_sc_hd__tapvpwrvgnd_1
XFILLER_102_144 VGND VGND VPWR VPWR sky130_fd_sc_hd__fill_2
XFILLER_103_645 VGND VGND VPWR VPWR sky130_fd_sc_hd__decap_3
X_6278_ _6280_/A VGND VGND VPWR VPWR _6278_/Y sky130_fd_sc_hd__inv_2
XFILLER_102_188 VGND VGND VPWR VPWR sky130_fd_sc_hd__decap_3
XFILLER_88_378 VGND VGND VPWR VPWR sky130_fd_sc_hd__decap_3
X_5229_ _5362_/C _5229_/B _5229_/C VGND VGND VPWR VPWR _5245_/S sky130_fd_sc_hd__and3b_2
XFILLER_56_25 VGND VGND VPWR VPWR sky130_fd_sc_hd__decap_3
XFILLER_56_253 VGND VGND VPWR VPWR sky130_fd_sc_hd__decap_3
XFILLER_84_573 VGND VGND VPWR VPWR sky130_fd_sc_hd__decap_3
XTAP_TAPCELL_ROW_55_911 VGND VPWR sky130_fd_sc_hd__tapvpwrvgnd_1
XFILLER_112_20 VGND VGND VPWR VPWR sky130_fd_sc_hd__decap_3
XFILLER_71_223 VGND VGND VPWR VPWR sky130_fd_sc_hd__fill_1
XFILLER_84_595 VGND VGND VPWR VPWR sky130_fd_sc_hd__decap_3
XTAP_TAPCELL_ROW_106_1519 VGND VPWR sky130_fd_sc_hd__tapvpwrvgnd_1
XFILLER_112_53 VGND VGND VPWR VPWR sky130_fd_sc_hd__decap_3
XFILLER_112_97 VGND VGND VPWR VPWR sky130_fd_sc_hd__decap_3
XFILLER_12_312 VGND VGND VPWR VPWR sky130_fd_sc_hd__decap_3
XFILLER_24_150 VGND VGND VPWR VPWR sky130_fd_sc_hd__decap_3
XFILLER_25_673 VGND VGND VPWR VPWR sky130_fd_sc_hd__fill_2
XFILLER_72_57 VGND VGND VPWR VPWR sky130_fd_sc_hd__fill_1
XFILLER_12_345 VGND VGND VPWR VPWR sky130_fd_sc_hd__decap_3
XFILLER_40_665 VGND VGND VPWR VPWR sky130_fd_sc_hd__decap_3
XFILLER_21_50 VGND VGND VPWR VPWR sky130_fd_sc_hd__decap_3
XFILLER_4_533 VGND VGND VPWR VPWR sky130_fd_sc_hd__fill_2
XFILLER_21_83 VGND VGND VPWR VPWR sky130_fd_sc_hd__fill_2
XFILLER_97_21 VGND VGND VPWR VPWR sky130_fd_sc_hd__decap_3
XFILLER_106_494 VGND VGND VPWR VPWR sky130_fd_sc_hd__decap_3
XFILLER_79_334 VGND VGND VPWR VPWR sky130_fd_sc_hd__fill_2
XFILLER_79_356 VGND VGND VPWR VPWR sky130_fd_sc_hd__fill_2
XFILLER_97_98 VGND VGND VPWR VPWR sky130_fd_sc_hd__decap_3
XFILLER_97_76 VGND VGND VPWR VPWR sky130_fd_sc_hd__fill_1
XFILLER_39_209 VGND VGND VPWR VPWR sky130_fd_sc_hd__decap_3
XFILLER_94_315 VGND VGND VPWR VPWR sky130_fd_sc_hd__decap_3
XFILLER_94_348 VGND VGND VPWR VPWR sky130_fd_sc_hd__fill_2
XFILLER_94_359 VGND VGND VPWR VPWR sky130_fd_sc_hd__decap_3
XFILLER_35_437 VGND VGND VPWR VPWR sky130_fd_sc_hd__decap_3
XFILLER_62_212 VGND VGND VPWR VPWR sky130_fd_sc_hd__decap_3
XFILLER_46_91 VGND VGND VPWR VPWR sky130_fd_sc_hd__decap_3
XFILLER_90_554 VGND VGND VPWR VPWR sky130_fd_sc_hd__fill_1
XFILLER_15_150 VGND VGND VPWR VPWR sky130_fd_sc_hd__decap_3
XFILLER_16_662 VGND VGND VPWR VPWR sky130_fd_sc_hd__fill_2
XFILLER_22_109 VGND VGND VPWR VPWR sky130_fd_sc_hd__decap_3
XFILLER_15_172 VGND VGND VPWR VPWR sky130_fd_sc_hd__decap_3
XTAP_TAPCELL_ROW_33_649 VGND VPWR sky130_fd_sc_hd__tapvpwrvgnd_1
XFILLER_30_164 VGND VGND VPWR VPWR sky130_fd_sc_hd__decap_3
XFILLER_31_665 VGND VGND VPWR VPWR sky130_fd_sc_hd__decap_3
XFILLER_30_197 VGND VGND VPWR VPWR sky130_fd_sc_hd__decap_3
XFILLER_7_30 VGND VGND VPWR VPWR sky130_fd_sc_hd__decap_3
XTAP_TAPCELL_ROW_96_1401 VGND VPWR sky130_fd_sc_hd__tapvpwrvgnd_1
XFILLER_116_203 VGND VGND VPWR VPWR sky130_fd_sc_hd__decap_3
XFILLER_7_63 VGND VGND VPWR VPWR sky130_fd_sc_hd__decap_3
XFILLER_116_225 VGND VGND VPWR VPWR sky130_fd_sc_hd__decap_3
XFILLER_7_393 VGND VGND VPWR VPWR sky130_fd_sc_hd__fill_2
XFILLER_7_96 VGND VGND VPWR VPWR sky130_fd_sc_hd__decap_3
X_7250_ clkload6/A _7250_/D _6530_/Y VGND VGND VPWR VPWR _7250_/Q sky130_fd_sc_hd__dfrtp_2
X_4462_ _3621_/B _3618_/X _3541_/X VGND VGND VPWR VPWR _4462_/Y sky130_fd_sc_hd__o21ai_2
XFILLER_89_109 VGND VGND VPWR VPWR sky130_fd_sc_hd__decap_3
X_3413_ _7155_/Q _4352_/B1 _3410_/X _3412_/X VGND VGND VPWR VPWR _3413_/X sky130_fd_sc_hd__a211o_2
X_7181_ _7372_/CLK _7181_/D _6461_/Y VGND VGND VPWR VPWR _7181_/Q sky130_fd_sc_hd__dfrtp_2
X_4393_ _7305_/Q _4772_/S _4434_/A2 _7113_/Q _4392_/X VGND VGND VPWR VPWR _4393_/X
+ sky130_fd_sc_hd__a221o_2
XFILLER_98_632 VGND VGND VPWR VPWR sky130_fd_sc_hd__decap_3
XFILLER_112_442 VGND VGND VPWR VPWR sky130_fd_sc_hd__decap_3
XFILLER_97_131 VGND VGND VPWR VPWR sky130_fd_sc_hd__decap_3
X_3344_ _3519_/B _5118_/D VGND VGND VPWR VPWR _3344_/Y sky130_fd_sc_hd__nor2_2
XTAP_TAPCELL_ROW_5_308 VGND VPWR sky130_fd_sc_hd__tapvpwrvgnd_1
XFILLER_98_654 VGND VGND VPWR VPWR sky130_fd_sc_hd__decap_3
XFILLER_85_315 VGND VGND VPWR VPWR sky130_fd_sc_hd__decap_3
Xhold1005 _7209_/Q VGND VGND VPWR VPWR _5241_/A0 sky130_fd_sc_hd__dlygate4sd3_1
XFILLER_100_648 VGND VGND VPWR VPWR sky130_fd_sc_hd__decap_3
Xhold1016 _7039_/Q VGND VGND VPWR VPWR _5579_/A0 sky130_fd_sc_hd__dlygate4sd3_1
Xhold1027 _7265_/Q VGND VGND VPWR VPWR _4946_/A0 sky130_fd_sc_hd__dlygate4sd3_1
Xhold1038 _7259_/Q VGND VGND VPWR VPWR _5041_/A0 sky130_fd_sc_hd__dlygate4sd3_1
Xhold1049 _7246_/Q VGND VGND VPWR VPWR _5163_/A sky130_fd_sc_hd__dlygate4sd3_1
X_5014_ _6990_/Q _5014_/B VGND VGND VPWR VPWR _5015_/C sky130_fd_sc_hd__or2_2
XFILLER_38_253 VGND VGND VPWR VPWR sky130_fd_sc_hd__decap_3
XFILLER_66_551 VGND VGND VPWR VPWR sky130_fd_sc_hd__fill_2
XFILLER_66_562 VGND VGND VPWR VPWR sky130_fd_sc_hd__decap_3
XFILLER_66_595 VGND VGND VPWR VPWR sky130_fd_sc_hd__fill_1
XFILLER_26_448 VGND VGND VPWR VPWR sky130_fd_sc_hd__decap_3
XFILLER_53_234 VGND VGND VPWR VPWR sky130_fd_sc_hd__decap_3
XFILLER_81_543 VGND VGND VPWR VPWR sky130_fd_sc_hd__decap_3
X_6965_ _6965_/CLK _6965_/D VGND VGND VPWR VPWR _6965_/Q sky130_fd_sc_hd__dfxtp_2
XFILLER_34_470 VGND VGND VPWR VPWR sky130_fd_sc_hd__decap_3
XFILLER_53_267 VGND VGND VPWR VPWR sky130_fd_sc_hd__decap_3
XFILLER_81_587 VGND VGND VPWR VPWR sky130_fd_sc_hd__fill_2
X_6896_ _7005_/CLK _6896_/D VGND VGND VPWR VPWR _6896_/Q sky130_fd_sc_hd__dfxtp_2
XFILLER_21_131 VGND VGND VPWR VPWR sky130_fd_sc_hd__fill_1
XFILLER_42_27 VGND VGND VPWR VPWR sky130_fd_sc_hd__fill_1
XFILLER_42_38 VGND VGND VPWR VPWR sky130_fd_sc_hd__fill_2
XFILLER_42_49 VGND VGND VPWR VPWR sky130_fd_sc_hd__decap_3
XFILLER_21_164 VGND VGND VPWR VPWR sky130_fd_sc_hd__decap_3
XFILLER_21_175 VGND VGND VPWR VPWR sky130_fd_sc_hd__decap_3
XPHY_EDGE_ROW_86_Left_203 VGND VGND VPWR VPWR sky130_fd_sc_hd__decap_3
XFILLER_5_308 VGND VGND VPWR VPWR sky130_fd_sc_hd__decap_3
X_4729_ _4836_/S _4729_/B VGND VGND VPWR VPWR _4729_/Y sky130_fd_sc_hd__nand2_2
XFILLER_107_214 VGND VGND VPWR VPWR sky130_fd_sc_hd__fill_1
XFILLER_107_258 VGND VGND VPWR VPWR sky130_fd_sc_hd__fill_1
XFILLER_107_20 VGND VGND VPWR VPWR sky130_fd_sc_hd__decap_3
XFILLER_89_632 VGND VGND VPWR VPWR sky130_fd_sc_hd__decap_3
X_7379_ _7384_/CLK _7379_/D _6659_/Y VGND VGND VPWR VPWR _7379_/Q sky130_fd_sc_hd__dfrtp_2
Xhold850 _7063_/Q VGND VGND VPWR VPWR _7063_/D sky130_fd_sc_hd__dlygate4sd3_1
Xhold861 _7112_/Q VGND VGND VPWR VPWR _7112_/D sky130_fd_sc_hd__dlygate4sd3_1
Xhold872 _7110_/Q VGND VGND VPWR VPWR _7110_/D sky130_fd_sc_hd__dlygate4sd3_1
XFILLER_107_53 VGND VGND VPWR VPWR sky130_fd_sc_hd__decap_3
XFILLER_107_75 VGND VGND VPWR VPWR sky130_fd_sc_hd__decap_3
XFILLER_88_120 VGND VGND VPWR VPWR sky130_fd_sc_hd__decap_3
XFILLER_89_654 VGND VGND VPWR VPWR sky130_fd_sc_hd__decap_3
Xhold883 _7059_/Q VGND VGND VPWR VPWR _7059_/D sky130_fd_sc_hd__dlygate4sd3_1
Xhold894 _7072_/Q VGND VGND VPWR VPWR _7072_/D sky130_fd_sc_hd__dlygate4sd3_1
XFILLER_103_475 VGND VGND VPWR VPWR sky130_fd_sc_hd__decap_3
XFILLER_67_24 VGND VGND VPWR VPWR sky130_fd_sc_hd__decap_3
XFILLER_76_304 VGND VGND VPWR VPWR sky130_fd_sc_hd__decap_3
XFILLER_76_315 VGND VGND VPWR VPWR sky130_fd_sc_hd__decap_3
XFILLER_89_676 VGND VGND VPWR VPWR sky130_fd_sc_hd__decap_3
XPHY_EDGE_ROW_95_Left_212 VGND VGND VPWR VPWR sky130_fd_sc_hd__decap_3
XFILLER_103_497 VGND VGND VPWR VPWR sky130_fd_sc_hd__decap_3
XFILLER_88_186 VGND VGND VPWR VPWR sky130_fd_sc_hd__decap_3
XFILLER_29_242 VGND VGND VPWR VPWR sky130_fd_sc_hd__decap_3
XFILLER_17_437 VGND VGND VPWR VPWR sky130_fd_sc_hd__decap_3
XFILLER_57_595 VGND VGND VPWR VPWR sky130_fd_sc_hd__fill_2
XFILLER_72_521 VGND VGND VPWR VPWR sky130_fd_sc_hd__fill_2
XFILLER_84_392 VGND VGND VPWR VPWR sky130_fd_sc_hd__fill_1
XTAP_TAPCELL_ROW_67_1057 VGND VPWR sky130_fd_sc_hd__tapvpwrvgnd_1
XFILLER_16_50 VGND VGND VPWR VPWR sky130_fd_sc_hd__decap_3
XFILLER_32_407 VGND VGND VPWR VPWR sky130_fd_sc_hd__decap_3
XFILLER_44_278 VGND VGND VPWR VPWR sky130_fd_sc_hd__decap_3
XFILLER_72_576 VGND VGND VPWR VPWR sky130_fd_sc_hd__fill_1
XFILLER_83_89 VGND VGND VPWR VPWR sky130_fd_sc_hd__decap_3
XFILLER_16_83 VGND VGND VPWR VPWR sky130_fd_sc_hd__fill_1
XTAP_TAPCELL_ROW_80_1213 VGND VPWR sky130_fd_sc_hd__tapvpwrvgnd_1
XFILLER_13_676 VGND VGND VPWR VPWR sky130_fd_sc_hd__fill_1
XFILLER_40_462 VGND VGND VPWR VPWR sky130_fd_sc_hd__decap_3
XTAP_TAPCELL_ROW_30_608 VGND VPWR sky130_fd_sc_hd__tapvpwrvgnd_1
XFILLER_9_625 VGND VGND VPWR VPWR sky130_fd_sc_hd__decap_3
XFILLER_9_603 VGND VGND VPWR VPWR sky130_fd_sc_hd__decap_3
XFILLER_12_186 VGND VGND VPWR VPWR sky130_fd_sc_hd__decap_3
XFILLER_8_135 VGND VGND VPWR VPWR sky130_fd_sc_hd__decap_3
XFILLER_12_197 VGND VGND VPWR VPWR sky130_fd_sc_hd__decap_3
XFILLER_32_71 VGND VGND VPWR VPWR sky130_fd_sc_hd__decap_3
XFILLER_66_9 VGND VGND VPWR VPWR sky130_fd_sc_hd__fill_2
XTAP_TAPCELL_ROW_10_376 VGND VPWR sky130_fd_sc_hd__tapvpwrvgnd_1
XTAP_TAPCELL_ROW_78_1186 VGND VPWR sky130_fd_sc_hd__tapvpwrvgnd_1
XFILLER_99_407 VGND VGND VPWR VPWR sky130_fd_sc_hd__decap_3
XFILLER_113_217 VGND VGND VPWR VPWR sky130_fd_sc_hd__decap_3
XFILLER_113_228 VGND VGND VPWR VPWR sky130_fd_sc_hd__decap_3
XFILLER_79_131 VGND VGND VPWR VPWR sky130_fd_sc_hd__decap_3
XTAP_TAPCELL_ROW_91_1342 VGND VPWR sky130_fd_sc_hd__tapvpwrvgnd_1
XFILLER_67_315 VGND VGND VPWR VPWR sky130_fd_sc_hd__decap_3
XFILLER_79_164 VGND VGND VPWR VPWR sky130_fd_sc_hd__decap_3
XFILLER_79_175 VGND VGND VPWR VPWR sky130_fd_sc_hd__decap_3
XFILLER_95_602 VGND VGND VPWR VPWR sky130_fd_sc_hd__decap_3
XFILLER_67_337 VGND VGND VPWR VPWR sky130_fd_sc_hd__fill_1
XFILLER_48_562 VGND VGND VPWR VPWR sky130_fd_sc_hd__fill_1
XFILLER_82_318 VGND VGND VPWR VPWR sky130_fd_sc_hd__decap_3
XFILLER_94_167 VGND VGND VPWR VPWR sky130_fd_sc_hd__decap_3
XFILLER_95_668 VGND VGND VPWR VPWR sky130_fd_sc_hd__decap_3
XFILLER_95_679 VGND VGND VPWR VPWR sky130_fd_sc_hd__decap_3
XTAP_TAPCELL_ROW_38_708 VGND VPWR sky130_fd_sc_hd__tapvpwrvgnd_1
XFILLER_57_90 VGND VGND VPWR VPWR sky130_fd_sc_hd__fill_1
XFILLER_35_223 VGND VGND VPWR VPWR sky130_fd_sc_hd__fill_1
XFILLER_35_256 VGND VGND VPWR VPWR sky130_fd_sc_hd__decap_3
XFILLER_63_532 VGND VGND VPWR VPWR sky130_fd_sc_hd__decap_3
XFILLER_35_278 VGND VGND VPWR VPWR sky130_fd_sc_hd__fill_2
XFILLER_90_351 VGND VGND VPWR VPWR sky130_fd_sc_hd__decap_3
X_6750_ _6978_/CLK _6750_/D VGND VGND VPWR VPWR _6750_/Q sky130_fd_sc_hd__dfxtp_2
XTAP_TAPCELL_ROW_18_465 VGND VPWR sky130_fd_sc_hd__tapvpwrvgnd_1
X_5701_ _7356_/Q hold934/X _5719_/S VGND VGND VPWR VPWR _6700_/D sky130_fd_sc_hd__mux2_2
X_3962_ _7359_/Q _4505_/A0 _3962_/S VGND VGND VPWR VPWR _7359_/D sky130_fd_sc_hd__mux2_2
XFILLER_50_259 VGND VGND VPWR VPWR sky130_fd_sc_hd__decap_3
X_6681_ _6682_/A VGND VGND VPWR VPWR _6681_/Y sky130_fd_sc_hd__inv_2
X_3893_ _6759_/Q _3913_/A2 _3893_/B1 _6753_/Q _3892_/X VGND VGND VPWR VPWR _3893_/X
+ sky130_fd_sc_hd__a221o_2
X_5632_ _5632_/A VGND VGND VPWR VPWR _5633_/A sky130_fd_sc_hd__inv_2
X_5563_ hold953/X _4909_/A _4729_/B VGND VGND VPWR VPWR _7053_/D sky130_fd_sc_hd__a21bo_2
X_7302_ _7338_/CLK _7302_/D _6582_/Y VGND VGND VPWR VPWR _7302_/Q sky130_fd_sc_hd__dfrtp_2
XFILLER_104_206 VGND VGND VPWR VPWR sky130_fd_sc_hd__decap_3
X_7233_ _7363_/CLK _7233_/D _6513_/Y VGND VGND VPWR VPWR _7233_/Q sky130_fd_sc_hd__dfrtp_2
X_4445_ _4813_/A _4813_/B VGND VGND VPWR VPWR _4814_/B sky130_fd_sc_hd__nor2_2
X_7164_ _7264_/CLK _7164_/D _6444_/Y VGND VGND VPWR VPWR _7164_/Q sky130_fd_sc_hd__dfrtp_2
X_4376_ _4376_/A _4376_/B _4376_/C _4273_/D VGND VGND VPWR VPWR _4376_/X sky130_fd_sc_hd__or4b_2
XFILLER_100_401 VGND VGND VPWR VPWR sky130_fd_sc_hd__decap_3
XFILLER_58_315 VGND VGND VPWR VPWR sky130_fd_sc_hd__decap_3
XFILLER_86_624 VGND VGND VPWR VPWR sky130_fd_sc_hd__decap_3
X_3327_ _3371_/A _3353_/A VGND VGND VPWR VPWR _3328_/B sky130_fd_sc_hd__nor2_2
XFILLER_98_473 VGND VGND VPWR VPWR sky130_fd_sc_hd__decap_3
XFILLER_112_294 VGND VGND VPWR VPWR sky130_fd_sc_hd__decap_3
X_7095_ clkload7/A _7095_/D _6375_/Y VGND VGND VPWR VPWR _7095_/Q sky130_fd_sc_hd__dfrtp_2
XFILLER_100_445 VGND VGND VPWR VPWR sky130_fd_sc_hd__decap_3
XFILLER_100_467 VGND VGND VPWR VPWR sky130_fd_sc_hd__decap_3
XFILLER_37_27 VGND VGND VPWR VPWR sky130_fd_sc_hd__decap_3
XFILLER_58_359 VGND VGND VPWR VPWR sky130_fd_sc_hd__decap_3
XFILLER_86_668 VGND VGND VPWR VPWR sky130_fd_sc_hd__decap_3
XFILLER_100_489 VGND VGND VPWR VPWR sky130_fd_sc_hd__decap_3
XFILLER_66_381 VGND VGND VPWR VPWR sky130_fd_sc_hd__decap_3
XFILLER_73_318 VGND VGND VPWR VPWR sky130_fd_sc_hd__decap_3
XFILLER_94_690 VGND VGND VPWR VPWR sky130_fd_sc_hd__fill_2
XFILLER_26_245 VGND VGND VPWR VPWR sky130_fd_sc_hd__decap_3
XFILLER_81_340 VGND VGND VPWR VPWR sky130_fd_sc_hd__decap_3
XFILLER_26_256 VGND VGND VPWR VPWR sky130_fd_sc_hd__decap_3
XFILLER_26_289 VGND VGND VPWR VPWR sky130_fd_sc_hd__decap_3
XFILLER_41_204 VGND VGND VPWR VPWR sky130_fd_sc_hd__decap_3
XFILLER_41_215 VGND VGND VPWR VPWR sky130_fd_sc_hd__decap_3
XFILLER_54_598 VGND VGND VPWR VPWR sky130_fd_sc_hd__decap_3
XFILLER_81_373 VGND VGND VPWR VPWR sky130_fd_sc_hd__decap_3
XFILLER_41_237 VGND VGND VPWR VPWR sky130_fd_sc_hd__decap_3
XFILLER_53_48 VGND VGND VPWR VPWR sky130_fd_sc_hd__decap_3
X_6948_ _6965_/CLK _6948_/D VGND VGND VPWR VPWR _6948_/Q sky130_fd_sc_hd__dfxtp_2
X_6879_ _6931_/CLK _6879_/D VGND VGND VPWR VPWR _6879_/Q sky130_fd_sc_hd__dfxtp_2
XFILLER_6_606 VGND VGND VPWR VPWR sky130_fd_sc_hd__decap_3
XFILLER_5_105 VGND VGND VPWR VPWR sky130_fd_sc_hd__decap_3
XFILLER_5_116 VGND VGND VPWR VPWR sky130_fd_sc_hd__decap_3
XTAP_TAPCELL_ROW_114_1618 VGND VPWR sky130_fd_sc_hd__tapvpwrvgnd_1
XFILLER_108_589 VGND VGND VPWR VPWR sky130_fd_sc_hd__decap_3
XFILLER_78_23 VGND VGND VPWR VPWR sky130_fd_sc_hd__decap_3
XFILLER_78_67 VGND VGND VPWR VPWR sky130_fd_sc_hd__decap_3
Xhold680 _6888_/Q VGND VGND VPWR VPWR _6888_/D sky130_fd_sc_hd__dlygate4sd3_1
XFILLER_110_209 VGND VGND VPWR VPWR sky130_fd_sc_hd__decap_3
XFILLER_89_462 VGND VGND VPWR VPWR sky130_fd_sc_hd__decap_3
Xhold691 _6916_/Q VGND VGND VPWR VPWR _6916_/D sky130_fd_sc_hd__dlygate4sd3_1
XFILLER_103_272 VGND VGND VPWR VPWR sky130_fd_sc_hd__decap_3
XFILLER_1_399 VGND VGND VPWR VPWR sky130_fd_sc_hd__decap_3
XFILLER_49_326 VGND VGND VPWR VPWR sky130_fd_sc_hd__fill_1
XFILLER_49_337 VGND VGND VPWR VPWR sky130_fd_sc_hd__fill_1
XFILLER_49_359 VGND VGND VPWR VPWR sky130_fd_sc_hd__fill_1
XFILLER_77_668 VGND VGND VPWR VPWR sky130_fd_sc_hd__decap_3
XFILLER_77_679 VGND VGND VPWR VPWR sky130_fd_sc_hd__decap_3
XFILLER_92_605 VGND VGND VPWR VPWR sky130_fd_sc_hd__fill_2
XFILLER_64_318 VGND VGND VPWR VPWR sky130_fd_sc_hd__decap_3
XFILLER_76_178 VGND VGND VPWR VPWR sky130_fd_sc_hd__decap_3
XFILLER_17_234 VGND VGND VPWR VPWR sky130_fd_sc_hd__decap_3
XFILLER_94_99 VGND VGND VPWR VPWR sky130_fd_sc_hd__decap_3
XFILLER_17_267 VGND VGND VPWR VPWR sky130_fd_sc_hd__decap_3
XFILLER_60_513 VGND VGND VPWR VPWR sky130_fd_sc_hd__decap_3
XFILLER_17_289 VGND VGND VPWR VPWR sky130_fd_sc_hd__decap_3
XFILLER_32_215 VGND VGND VPWR VPWR sky130_fd_sc_hd__decap_3
XTAP_TAPCELL_ROW_15_435 VGND VPWR sky130_fd_sc_hd__tapvpwrvgnd_1
XFILLER_32_259 VGND VGND VPWR VPWR sky130_fd_sc_hd__decap_3
XTAP_TAPCELL_ROW_43_766 VGND VPWR sky130_fd_sc_hd__tapvpwrvgnd_1
XFILLER_13_495 VGND VGND VPWR VPWR sky130_fd_sc_hd__fill_1
XFILLER_40_292 VGND VGND VPWR VPWR sky130_fd_sc_hd__decap_3
XFILLER_64_6 VGND VGND VPWR VPWR sky130_fd_sc_hd__decap_3
XFILLER_114_504 VGND VGND VPWR VPWR sky130_fd_sc_hd__decap_3
XFILLER_5_661 VGND VGND VPWR VPWR sky130_fd_sc_hd__decap_3
X_4230_ _7227_/Q _4230_/A2 _5159_/S _7291_/Q _4229_/X VGND VGND VPWR VPWR _4230_/X
+ sky130_fd_sc_hd__a221o_2
XFILLER_99_248 VGND VGND VPWR VPWR sky130_fd_sc_hd__decap_3
XFILLER_4_53 VGND VGND VPWR VPWR sky130_fd_sc_hd__decap_3
XFILLER_68_602 VGND VGND VPWR VPWR sky130_fd_sc_hd__decap_3
X_4161_ _7265_/Q _4422_/A2 _4349_/B1 _7233_/Q _4160_/X VGND VGND VPWR VPWR _4161_/X
+ sky130_fd_sc_hd__a221o_2
XFILLER_4_97 VGND VGND VPWR VPWR sky130_fd_sc_hd__decap_3
XFILLER_95_410 VGND VGND VPWR VPWR sky130_fd_sc_hd__decap_3
XFILLER_67_167 VGND VGND VPWR VPWR sky130_fd_sc_hd__fill_1
XFILLER_83_605 VGND VGND VPWR VPWR sky130_fd_sc_hd__fill_2
XFILLER_95_476 VGND VGND VPWR VPWR sky130_fd_sc_hd__decap_3
X_4092_ _7366_/Q _4435_/B1 _4436_/B1 _7174_/Q _4091_/X VGND VGND VPWR VPWR _4092_/X
+ sky130_fd_sc_hd__a221o_2
XFILLER_36_521 VGND VGND VPWR VPWR sky130_fd_sc_hd__fill_2
XFILLER_55_318 VGND VGND VPWR VPWR sky130_fd_sc_hd__decap_3
XFILLER_82_115 VGND VGND VPWR VPWR sky130_fd_sc_hd__decap_3
XFILLER_83_638 VGND VGND VPWR VPWR sky130_fd_sc_hd__decap_3
XFILLER_63_340 VGND VGND VPWR VPWR sky130_fd_sc_hd__decap_3
XFILLER_76_690 VGND VGND VPWR VPWR sky130_fd_sc_hd__fill_2
XFILLER_82_159 VGND VGND VPWR VPWR sky130_fd_sc_hd__fill_2
XFILLER_51_513 VGND VGND VPWR VPWR sky130_fd_sc_hd__decap_3
XFILLER_63_373 VGND VGND VPWR VPWR sky130_fd_sc_hd__decap_3
XFILLER_91_682 VGND VGND VPWR VPWR sky130_fd_sc_hd__decap_3
Xplace340 _4606_/Y VGND VGND VPWR VPWR _5092_/C sky130_fd_sc_hd__buf_2
X_6802_ _7406_/CLK _6802_/D VGND VGND VPWR VPWR _6802_/Q sky130_fd_sc_hd__dfxtp_2
Xplace373 _3339_/Y VGND VGND VPWR VPWR _3469_/A sky130_fd_sc_hd__buf_2
Xplace362 _4305_/B VGND VGND VPWR VPWR _4265_/B sky130_fd_sc_hd__buf_2
Xplace351 _5136_/S VGND VGND VPWR VPWR _5159_/S sky130_fd_sc_hd__buf_2
X_4994_ _5114_/A wire560/X _4987_/A _5033_/B2 VGND VGND VPWR VPWR _4994_/X sky130_fd_sc_hd__a22o_2
XFILLER_23_18 VGND VGND VPWR VPWR sky130_fd_sc_hd__decap_3
XFILLER_23_259 VGND VGND VPWR VPWR sky130_fd_sc_hd__decap_3
Xplace384 _5194_/B VGND VGND VPWR VPWR _5182_/B sky130_fd_sc_hd__buf_2
Xplace395 _5350_/S VGND VGND VPWR VPWR _5360_/S sky130_fd_sc_hd__buf_2
X_6733_ _6972_/CLK _6733_/D VGND VGND VPWR VPWR _6733_/Q sky130_fd_sc_hd__dfxtp_2
X_3945_ _7367_/Q _4488_/A0 _3945_/S VGND VGND VPWR VPWR _7367_/D sky130_fd_sc_hd__mux2_2
X_6664_ _6664_/A VGND VGND VPWR VPWR _6664_/Y sky130_fd_sc_hd__inv_2
XFILLER_109_309 VGND VGND VPWR VPWR sky130_fd_sc_hd__decap_3
XFILLER_31_281 VGND VGND VPWR VPWR sky130_fd_sc_hd__decap_3
X_5615_ _5615_/A _5633_/B VGND VGND VPWR VPWR _7020_/D sky130_fd_sc_hd__or2_2
X_3876_ _6858_/Q _3891_/A2 _3878_/B1 _6898_/Q VGND VGND VPWR VPWR _3876_/X sky130_fd_sc_hd__a22o_2
X_6595_ _6635_/A VGND VGND VPWR VPWR _6595_/Y sky130_fd_sc_hd__inv_2
XFILLER_3_609 VGND VGND VPWR VPWR sky130_fd_sc_hd__decap_3
XFILLER_105_537 VGND VGND VPWR VPWR sky130_fd_sc_hd__decap_3
X_7216_ _7356_/CLK _7216_/D _6496_/Y VGND VGND VPWR VPWR _7216_/Q sky130_fd_sc_hd__dfrtp_2
X_4428_ _7335_/Q _3945_/S _4428_/B1 _7143_/Q VGND VGND VPWR VPWR _4428_/X sky130_fd_sc_hd__a22o_2
XFILLER_59_613 VGND VGND VPWR VPWR sky130_fd_sc_hd__decap_3
XFILLER_59_635 VGND VGND VPWR VPWR sky130_fd_sc_hd__decap_3
XFILLER_86_421 VGND VGND VPWR VPWR sky130_fd_sc_hd__decap_3
X_7147_ _7372_/CLK _7147_/D _6427_/Y VGND VGND VPWR VPWR _7147_/Q sky130_fd_sc_hd__dfrtp_2
X_4359_ _4367_/C _4367_/A _4367_/B VGND VGND VPWR VPWR _5071_/B sky130_fd_sc_hd__nand3b_2
XFILLER_100_231 VGND VGND VPWR VPWR sky130_fd_sc_hd__decap_3
XFILLER_100_253 VGND VGND VPWR VPWR sky130_fd_sc_hd__decap_3
XFILLER_104_21 VGND VGND VPWR VPWR sky130_fd_sc_hd__decap_3
XFILLER_58_134 VGND VGND VPWR VPWR sky130_fd_sc_hd__fill_1
XFILLER_59_668 VGND VGND VPWR VPWR sky130_fd_sc_hd__decap_3
XFILLER_59_679 VGND VGND VPWR VPWR sky130_fd_sc_hd__decap_3
XFILLER_74_616 VGND VGND VPWR VPWR sky130_fd_sc_hd__fill_1
XFILLER_86_454 VGND VGND VPWR VPWR sky130_fd_sc_hd__decap_3
X_7078_ _7266_/CLK _7078_/D _6358_/Y VGND VGND VPWR VPWR _7078_/Q sky130_fd_sc_hd__dfrtp_2
XFILLER_104_32 VGND VGND VPWR VPWR sky130_fd_sc_hd__decap_3
XFILLER_46_329 VGND VGND VPWR VPWR sky130_fd_sc_hd__decap_3
XFILLER_58_189 VGND VGND VPWR VPWR sky130_fd_sc_hd__decap_3
XFILLER_73_104 VGND VGND VPWR VPWR sky130_fd_sc_hd__decap_3
XFILLER_74_638 VGND VGND VPWR VPWR sky130_fd_sc_hd__decap_3
XFILLER_86_498 VGND VGND VPWR VPWR sky130_fd_sc_hd__decap_3
XFILLER_27_532 VGND VGND VPWR VPWR sky130_fd_sc_hd__decap_3
XFILLER_27_576 VGND VGND VPWR VPWR sky130_fd_sc_hd__decap_3
XFILLER_42_502 VGND VGND VPWR VPWR sky130_fd_sc_hd__decap_3
XFILLER_82_660 VGND VGND VPWR VPWR sky130_fd_sc_hd__decap_3
XFILLER_14_215 VGND VGND VPWR VPWR sky130_fd_sc_hd__decap_3
XFILLER_54_395 VGND VGND VPWR VPWR sky130_fd_sc_hd__decap_3
XTAP_TAPCELL_ROW_64_1016 VGND VPWR sky130_fd_sc_hd__tapvpwrvgnd_1
XFILLER_14_259 VGND VGND VPWR VPWR sky130_fd_sc_hd__fill_2
Xfanout30 fanout38/X VGND VGND VPWR VPWR _6535_/A sky130_fd_sc_hd__clkbuf_2
XFILLER_10_410 VGND VGND VPWR VPWR sky130_fd_sc_hd__fill_1
XFILLER_80_35 VGND VGND VPWR VPWR sky130_fd_sc_hd__decap_3
Xfanout41 _6547_/A VGND VGND VPWR VPWR _6610_/A sky130_fd_sc_hd__clkdlybuf4s25_1
Xfanout52 _6686_/A VGND VGND VPWR VPWR _6660_/A sky130_fd_sc_hd__buf_2
Xfanout63 fanout72/X VGND VGND VPWR VPWR _6682_/A sky130_fd_sc_hd__buf_2
XTAP_TAPCELL_ROW_40_736 VGND VPWR sky130_fd_sc_hd__tapvpwrvgnd_1
XFILLER_10_421 VGND VGND VPWR VPWR sky130_fd_sc_hd__fill_1
XFILLER_10_443 VGND VGND VPWR VPWR sky130_fd_sc_hd__decap_3
XFILLER_22_281 VGND VGND VPWR VPWR sky130_fd_sc_hd__decap_3
XFILLER_80_68 VGND VGND VPWR VPWR sky130_fd_sc_hd__decap_3
XTAP_TAPCELL_ROW_20_493 VGND VPWR sky130_fd_sc_hd__tapvpwrvgnd_1
XFILLER_89_66 VGND VGND VPWR VPWR sky130_fd_sc_hd__decap_3
XFILLER_2_642 VGND VGND VPWR VPWR sky130_fd_sc_hd__fill_2
XFILLER_89_99 VGND VGND VPWR VPWR sky130_fd_sc_hd__decap_3
XTAP_TAPCELL_ROW_75_1156 VGND VPWR sky130_fd_sc_hd__tapvpwrvgnd_1
XFILLER_111_529 VGND VGND VPWR VPWR sky130_fd_sc_hd__decap_3
XFILLER_2_675 VGND VGND VPWR VPWR sky130_fd_sc_hd__decap_3
XFILLER_104_581 VGND VGND VPWR VPWR sky130_fd_sc_hd__decap_3
XFILLER_104_592 VGND VGND VPWR VPWR sky130_fd_sc_hd__fill_1
XFILLER_29_9 VGND VGND VPWR VPWR sky130_fd_sc_hd__decap_3
XFILLER_89_281 VGND VGND VPWR VPWR sky130_fd_sc_hd__fill_1
XFILLER_65_605 VGND VGND VPWR VPWR sky130_fd_sc_hd__decap_3
XFILLER_77_443 VGND VGND VPWR VPWR sky130_fd_sc_hd__decap_3
XFILLER_38_70 VGND VGND VPWR VPWR sky130_fd_sc_hd__decap_3
XFILLER_38_81 VGND VGND VPWR VPWR sky130_fd_sc_hd__decap_3
XFILLER_49_167 VGND VGND VPWR VPWR sky130_fd_sc_hd__fill_1
XFILLER_49_189 VGND VGND VPWR VPWR sky130_fd_sc_hd__decap_3
XFILLER_65_638 VGND VGND VPWR VPWR sky130_fd_sc_hd__decap_3
XFILLER_77_476 VGND VGND VPWR VPWR sky130_fd_sc_hd__decap_3
XFILLER_92_402 VGND VGND VPWR VPWR sky130_fd_sc_hd__decap_3
XFILLER_92_424 VGND VGND VPWR VPWR sky130_fd_sc_hd__fill_1
XTAP_TAPCELL_ROW_48_825 VGND VPWR sky130_fd_sc_hd__tapvpwrvgnd_1
XFILLER_92_446 VGND VGND VPWR VPWR sky130_fd_sc_hd__decap_3
XPHY_EDGE_ROW_32_Left_149 VGND VGND VPWR VPWR sky130_fd_sc_hd__decap_3
XFILLER_18_587 VGND VGND VPWR VPWR sky130_fd_sc_hd__fill_1
XFILLER_45_340 VGND VGND VPWR VPWR sky130_fd_sc_hd__fill_2
XFILLER_73_660 VGND VGND VPWR VPWR sky130_fd_sc_hd__decap_3
XFILLER_73_671 VGND VGND VPWR VPWR sky130_fd_sc_hd__fill_1
XFILLER_33_535 VGND VGND VPWR VPWR sky130_fd_sc_hd__decap_3
XFILLER_60_321 VGND VGND VPWR VPWR sky130_fd_sc_hd__decap_3
XFILLER_72_170 VGND VGND VPWR VPWR sky130_fd_sc_hd__decap_3
XFILLER_73_682 VGND VGND VPWR VPWR sky130_fd_sc_hd__fill_2
XTAP_TAPCELL_ROW_86_1285 VGND VPWR sky130_fd_sc_hd__tapvpwrvgnd_1
XTAP_TAPCELL_ROW_28_593 VGND VPWR sky130_fd_sc_hd__tapvpwrvgnd_1
XTAP_TAPCELL_ROW_28_582 VGND VPWR sky130_fd_sc_hd__tapvpwrvgnd_1
XFILLER_33_557 VGND VGND VPWR VPWR sky130_fd_sc_hd__decap_3
XFILLER_54_80 VGND VGND VPWR VPWR sky130_fd_sc_hd__decap_3
XFILLER_54_91 VGND VGND VPWR VPWR sky130_fd_sc_hd__decap_3
XFILLER_60_354 VGND VGND VPWR VPWR sky130_fd_sc_hd__fill_1
XFILLER_60_365 VGND VGND VPWR VPWR sky130_fd_sc_hd__decap_3
XFILLER_13_270 VGND VGND VPWR VPWR sky130_fd_sc_hd__fill_2
X_3730_ _6956_/Q _3889_/A2 _3889_/B1 _6950_/Q _3729_/X VGND VGND VPWR VPWR _3730_/X
+ sky130_fd_sc_hd__a221o_2
XFILLER_13_281 VGND VGND VPWR VPWR sky130_fd_sc_hd__decap_3
X_3661_ _3991_/B _3665_/B VGND VGND VPWR VPWR _3661_/X sky130_fd_sc_hd__and2_4
XFILLER_62_3 VGND VGND VPWR VPWR sky130_fd_sc_hd__decap_3
Xclkload11 _7384_/CLK VGND VGND VPWR VPWR clkload11/X sky130_fd_sc_hd__clkbuf_1
Xclkload22 _7264_/CLK VGND VGND VPWR VPWR clkload22/X sky130_fd_sc_hd__clkbuf_1
Xclkload33 _7392_/CLK VGND VGND VPWR VPWR clkload33/Y sky130_fd_sc_hd__clkinv_2
X_6380_ _6540_/A VGND VGND VPWR VPWR _6380_/Y sky130_fd_sc_hd__inv_2
X_5400_ _7133_/Q _5011_/X _5417_/S VGND VGND VPWR VPWR _7133_/D sky130_fd_sc_hd__mux2_2
X_3592_ _4292_/B _3620_/C _3591_/Y VGND VGND VPWR VPWR _3592_/X sky130_fd_sc_hd__a21o_2
XPHY_EDGE_ROW_41_Left_158 VGND VGND VPWR VPWR sky130_fd_sc_hd__decap_3
XFILLER_114_312 VGND VGND VPWR VPWR sky130_fd_sc_hd__decap_3
X_5331_ _7165_/Q _5011_/X _5350_/S VGND VGND VPWR VPWR _7165_/D sky130_fd_sc_hd__mux2_2
XFILLER_5_491 VGND VGND VPWR VPWR sky130_fd_sc_hd__fill_1
XFILLER_114_356 VGND VGND VPWR VPWR sky130_fd_sc_hd__decap_3
X_7001_ _7341_/CLK _7001_/D _6281_/Y VGND VGND VPWR VPWR _7001_/Q sky130_fd_sc_hd__dfrtp_2
X_5262_ _5262_/A0 _4978_/X _5262_/S VGND VGND VPWR VPWR _7199_/D sky130_fd_sc_hd__mux2_2
XFILLER_68_410 VGND VGND VPWR VPWR sky130_fd_sc_hd__decap_3
XFILLER_68_421 VGND VGND VPWR VPWR sky130_fd_sc_hd__fill_2
X_4213_ _7292_/Q _4517_/S _4354_/B1 _7356_/Q _4419_/C1 VGND VGND VPWR VPWR _4213_/X
+ sky130_fd_sc_hd__a221o_2
XFILLER_68_443 VGND VGND VPWR VPWR sky130_fd_sc_hd__fill_1
X_4144_ _7362_/Q _4196_/A2 _4459_/C1 _7170_/Q VGND VGND VPWR VPWR _4144_/X sky130_fd_sc_hd__a22o_2
XFILLER_18_18 VGND VGND VPWR VPWR sky130_fd_sc_hd__decap_3
XFILLER_18_29 VGND VGND VPWR VPWR sky130_fd_sc_hd__decap_3
XFILLER_28_318 VGND VGND VPWR VPWR sky130_fd_sc_hd__fill_2
XFILLER_56_627 VGND VGND VPWR VPWR sky130_fd_sc_hd__decap_3
XFILLER_68_498 VGND VGND VPWR VPWR sky130_fd_sc_hd__fill_1
XFILLER_95_284 VGND VGND VPWR VPWR sky130_fd_sc_hd__decap_3
XPHY_EDGE_ROW_50_Left_167 VGND VGND VPWR VPWR sky130_fd_sc_hd__decap_3
XFILLER_110_595 VGND VGND VPWR VPWR sky130_fd_sc_hd__decap_3
XFILLER_55_137 VGND VGND VPWR VPWR sky130_fd_sc_hd__decap_3
X_4075_ _7211_/Q _3958_/S _4865_/S _7307_/Q VGND VGND VPWR VPWR _4075_/X sky130_fd_sc_hd__a22o_2
XFILLER_64_660 VGND VGND VPWR VPWR sky130_fd_sc_hd__decap_3
XFILLER_51_332 VGND VGND VPWR VPWR sky130_fd_sc_hd__fill_1
XFILLER_51_343 VGND VGND VPWR VPWR sky130_fd_sc_hd__decap_3
XFILLER_51_365 VGND VGND VPWR VPWR sky130_fd_sc_hd__fill_1
X_6716_ _7406_/CLK _6716_/D VGND VGND VPWR VPWR _6716_/Q sky130_fd_sc_hd__dfxtp_2
X_4977_ _4977_/A _4977_/B VGND VGND VPWR VPWR _6993_/D sky130_fd_sc_hd__nor2_2
Xclkload5 clkload5/A VGND VGND VPWR VPWR clkload5/X sky130_fd_sc_hd__clkbuf_16
X_3928_ hold973/X _5151_/A _3927_/X VGND VGND VPWR VPWR _7375_/D sky130_fd_sc_hd__o21a_2
XFILLER_109_106 VGND VGND VPWR VPWR sky130_fd_sc_hd__fill_2
X_6647_ _6647_/A VGND VGND VPWR VPWR _6647_/Y sky130_fd_sc_hd__inv_2
X_3859_ _6924_/Q _3926_/A2 _3926_/B1 _6788_/Q _3858_/X VGND VGND VPWR VPWR _3859_/X
+ sky130_fd_sc_hd__a221o_2
X_6578_ _6578_/A VGND VGND VPWR VPWR _6578_/Y sky130_fd_sc_hd__inv_2
XFILLER_3_417 VGND VGND VPWR VPWR sky130_fd_sc_hd__decap_3
XFILLER_105_345 VGND VGND VPWR VPWR sky130_fd_sc_hd__decap_3
XFILLER_115_20 VGND VGND VPWR VPWR sky130_fd_sc_hd__decap_3
XFILLER_59_421 VGND VGND VPWR VPWR sky130_fd_sc_hd__decap_3
XFILLER_99_590 VGND VGND VPWR VPWR sky130_fd_sc_hd__decap_3
XFILLER_115_53 VGND VGND VPWR VPWR sky130_fd_sc_hd__decap_3
XFILLER_47_605 VGND VGND VPWR VPWR sky130_fd_sc_hd__decap_3
XFILLER_115_75 VGND VGND VPWR VPWR sky130_fd_sc_hd__decap_3
XFILLER_19_307 VGND VGND VPWR VPWR sky130_fd_sc_hd__decap_3
XFILLER_19_318 VGND VGND VPWR VPWR sky130_fd_sc_hd__decap_3
XFILLER_46_104 VGND VGND VPWR VPWR sky130_fd_sc_hd__decap_3
XFILLER_47_638 VGND VGND VPWR VPWR sky130_fd_sc_hd__decap_3
XFILLER_75_46 VGND VGND VPWR VPWR sky130_fd_sc_hd__decap_3
XFILLER_86_251 VGND VGND VPWR VPWR sky130_fd_sc_hd__fill_1
XFILLER_86_262 VGND VGND VPWR VPWR sky130_fd_sc_hd__decap_3
XFILLER_86_284 VGND VGND VPWR VPWR sky130_fd_sc_hd__decap_3
XTAP_TAPCELL_ROW_70_1097 VGND VPWR sky130_fd_sc_hd__tapvpwrvgnd_1
XTAP_TAPCELL_ROW_70_1086 VGND VPWR sky130_fd_sc_hd__tapvpwrvgnd_1
XFILLER_74_435 VGND VGND VPWR VPWR sky130_fd_sc_hd__decap_3
XFILLER_74_457 VGND VGND VPWR VPWR sky130_fd_sc_hd__fill_1
XFILLER_75_57 VGND VGND VPWR VPWR sky130_fd_sc_hd__decap_3
XFILLER_55_671 VGND VGND VPWR VPWR sky130_fd_sc_hd__fill_1
XFILLER_15_535 VGND VGND VPWR VPWR sky130_fd_sc_hd__decap_3
XFILLER_55_682 VGND VGND VPWR VPWR sky130_fd_sc_hd__decap_3
XFILLER_61_129 VGND VGND VPWR VPWR sky130_fd_sc_hd__decap_3
XFILLER_91_12 VGND VGND VPWR VPWR sky130_fd_sc_hd__decap_3
XFILLER_42_332 VGND VGND VPWR VPWR sky130_fd_sc_hd__decap_3
XFILLER_91_45 VGND VGND VPWR VPWR sky130_fd_sc_hd__decap_3
XFILLER_42_365 VGND VGND VPWR VPWR sky130_fd_sc_hd__decap_3
XFILLER_42_387 VGND VGND VPWR VPWR sky130_fd_sc_hd__decap_3
XFILLER_70_685 VGND VGND VPWR VPWR sky130_fd_sc_hd__decap_3
XTAP_TAPCELL_ROW_53_883 VGND VPWR sky130_fd_sc_hd__tapvpwrvgnd_1
XTAP_TAPCELL_ROW_25_552 VGND VPWR sky130_fd_sc_hd__tapvpwrvgnd_1
XFILLER_24_72 VGND VGND VPWR VPWR sky130_fd_sc_hd__decap_3
XFILLER_10_240 VGND VGND VPWR VPWR sky130_fd_sc_hd__decap_3
XFILLER_10_262 VGND VGND VPWR VPWR sky130_fd_sc_hd__decap_3
XFILLER_6_200 VGND VGND VPWR VPWR sky130_fd_sc_hd__fill_1
XFILLER_6_222 VGND VGND VPWR VPWR sky130_fd_sc_hd__fill_1
XFILLER_109_662 VGND VGND VPWR VPWR sky130_fd_sc_hd__decap_3
XFILLER_109_673 VGND VGND VPWR VPWR sky130_fd_sc_hd__decap_3
XFILLER_6_277 VGND VGND VPWR VPWR sky130_fd_sc_hd__decap_3
XFILLER_97_505 VGND VGND VPWR VPWR sky130_fd_sc_hd__decap_3
XFILLER_111_337 VGND VGND VPWR VPWR sky130_fd_sc_hd__decap_3
XFILLER_27_6 VGND VGND VPWR VPWR sky130_fd_sc_hd__decap_3
XFILLER_1_32 VGND VGND VPWR VPWR sky130_fd_sc_hd__decap_3
XFILLER_37_104 VGND VGND VPWR VPWR sky130_fd_sc_hd__decap_3
XFILLER_38_627 VGND VGND VPWR VPWR sky130_fd_sc_hd__fill_1
XFILLER_65_402 VGND VGND VPWR VPWR sky130_fd_sc_hd__decap_3
XFILLER_77_262 VGND VGND VPWR VPWR sky130_fd_sc_hd__decap_3
XTAP_TAPCELL_ROW_88_1303 VGND VPWR sky130_fd_sc_hd__tapvpwrvgnd_1
XFILLER_37_126 VGND VGND VPWR VPWR sky130_fd_sc_hd__decap_3
XFILLER_18_351 VGND VGND VPWR VPWR sky130_fd_sc_hd__decap_3
XFILLER_1_87 VGND VGND VPWR VPWR sky130_fd_sc_hd__decap_3
XFILLER_46_660 VGND VGND VPWR VPWR sky130_fd_sc_hd__decap_3
XFILLER_80_416 VGND VGND VPWR VPWR sky130_fd_sc_hd__decap_3
XFILLER_92_265 VGND VGND VPWR VPWR sky130_fd_sc_hd__decap_3
XFILLER_18_373 VGND VGND VPWR VPWR sky130_fd_sc_hd__fill_2
XFILLER_45_181 VGND VGND VPWR VPWR sky130_fd_sc_hd__decap_3
XFILLER_80_438 VGND VGND VPWR VPWR sky130_fd_sc_hd__decap_3
XFILLER_45_192 VGND VGND VPWR VPWR sky130_fd_sc_hd__decap_3
XFILLER_61_641 VGND VGND VPWR VPWR sky130_fd_sc_hd__decap_3
X_4831_ _4969_/B _4827_/X _4828_/X _4830_/X VGND VGND VPWR VPWR _5657_/A sky130_fd_sc_hd__a211o_2
XFILLER_21_516 VGND VGND VPWR VPWR sky130_fd_sc_hd__decap_3
XFILLER_21_538 VGND VGND VPWR VPWR sky130_fd_sc_hd__decap_3
XFILLER_33_387 VGND VGND VPWR VPWR sky130_fd_sc_hd__decap_3
XFILLER_61_685 VGND VGND VPWR VPWR sky130_fd_sc_hd__decap_3
X_4762_ _4762_/A _4762_/B VGND VGND VPWR VPWR _4762_/Y sky130_fd_sc_hd__nor2_2
X_6501_ _6599_/A VGND VGND VPWR VPWR _6501_/Y sky130_fd_sc_hd__inv_2
X_4693_ _7007_/Q _4750_/B VGND VGND VPWR VPWR _4728_/A sky130_fd_sc_hd__nand2_2
X_3713_ _3733_/C VGND VGND VPWR VPWR _3746_/C sky130_fd_sc_hd__inv_4
XTAP_TAPCELL_ROW_99_1443 VGND VPWR sky130_fd_sc_hd__tapvpwrvgnd_1
X_6432_ _6637_/A VGND VGND VPWR VPWR _6432_/Y sky130_fd_sc_hd__inv_2
X_3644_ _3629_/Y _3642_/X _4799_/A VGND VGND VPWR VPWR _4664_/B sky130_fd_sc_hd__o21a_2
XFILLER_106_109 VGND VGND VPWR VPWR sky130_fd_sc_hd__decap_3
XFILLER_115_632 VGND VGND VPWR VPWR sky130_fd_sc_hd__decap_3
X_6363_ _6366_/A VGND VGND VPWR VPWR _6363_/Y sky130_fd_sc_hd__inv_2
X_3575_ _7156_/Q _4339_/B1 wire566/X _7124_/Q _3574_/X VGND VGND VPWR VPWR _3575_/X
+ sky130_fd_sc_hd__a221o_2
XFILLER_0_409 VGND VGND VPWR VPWR sky130_fd_sc_hd__decap_3
XFILLER_114_153 VGND VGND VPWR VPWR sky130_fd_sc_hd__decap_3
XFILLER_115_665 VGND VGND VPWR VPWR sky130_fd_sc_hd__decap_3
XFILLER_115_676 VGND VGND VPWR VPWR sky130_fd_sc_hd__decap_3
X_6294_ _6532_/A VGND VGND VPWR VPWR _6294_/Y sky130_fd_sc_hd__inv_2
XFILLER_102_326 VGND VGND VPWR VPWR sky130_fd_sc_hd__decap_3
XFILLER_114_186 VGND VGND VPWR VPWR sky130_fd_sc_hd__decap_3
X_5245_ _5245_/A0 _4836_/X _5245_/S VGND VGND VPWR VPWR _7207_/D sky130_fd_sc_hd__mux2_2
XFILLER_114_197 VGND VGND VPWR VPWR sky130_fd_sc_hd__decap_3
XFILLER_29_39 VGND VGND VPWR VPWR sky130_fd_sc_hd__decap_3
XFILLER_68_262 VGND VGND VPWR VPWR sky130_fd_sc_hd__decap_3
XFILLER_68_273 VGND VGND VPWR VPWR sky130_fd_sc_hd__decap_3
XFILLER_96_582 VGND VGND VPWR VPWR sky130_fd_sc_hd__decap_3
XFILLER_110_381 VGND VGND VPWR VPWR sky130_fd_sc_hd__decap_3
XFILLER_28_115 VGND VGND VPWR VPWR sky130_fd_sc_hd__decap_3
XFILLER_56_424 VGND VGND VPWR VPWR sky130_fd_sc_hd__decap_3
XFILLER_83_210 VGND VGND VPWR VPWR sky130_fd_sc_hd__decap_3
XFILLER_28_159 VGND VGND VPWR VPWR sky130_fd_sc_hd__decap_3
XFILLER_45_27 VGND VGND VPWR VPWR sky130_fd_sc_hd__decap_3
XFILLER_83_265 VGND VGND VPWR VPWR sky130_fd_sc_hd__decap_3
X_4058_ _7244_/Q _4430_/A2 _4430_/B1 _7180_/Q _4057_/X VGND VGND VPWR VPWR _4058_/X
+ sky130_fd_sc_hd__a221o_2
XTAP_TAPCELL_ROW_108_1550 VGND VPWR sky130_fd_sc_hd__tapvpwrvgnd_1
XFILLER_37_671 VGND VGND VPWR VPWR sky130_fd_sc_hd__fill_1
XFILLER_71_449 VGND VGND VPWR VPWR sky130_fd_sc_hd__decap_3
XFILLER_24_343 VGND VGND VPWR VPWR sky130_fd_sc_hd__decap_3
XFILLER_52_663 VGND VGND VPWR VPWR sky130_fd_sc_hd__decap_3
XFILLER_61_37 VGND VGND VPWR VPWR sky130_fd_sc_hd__decap_3
XTAP_TAPCELL_ROW_22_511 VGND VPWR sky130_fd_sc_hd__tapvpwrvgnd_1
XTAP_TAPCELL_ROW_50_853 VGND VPWR sky130_fd_sc_hd__tapvpwrvgnd_1
XFILLER_106_643 VGND VGND VPWR VPWR sky130_fd_sc_hd__fill_1
XFILLER_3_225 VGND VGND VPWR VPWR sky130_fd_sc_hd__decap_3
XFILLER_105_153 VGND VGND VPWR VPWR sky130_fd_sc_hd__decap_3
XFILLER_106_654 VGND VGND VPWR VPWR sky130_fd_sc_hd__decap_3
XFILLER_10_41 VGND VGND VPWR VPWR sky130_fd_sc_hd__decap_3
XFILLER_79_505 VGND VGND VPWR VPWR sky130_fd_sc_hd__decap_3
XTAP_TAPCELL_ROW_72_1115 VGND VPWR sky130_fd_sc_hd__tapvpwrvgnd_1
XFILLER_106_687 VGND VGND VPWR VPWR sky130_fd_sc_hd__decap_3
XFILLER_10_74 VGND VGND VPWR VPWR sky130_fd_sc_hd__decap_3
XFILLER_10_85 VGND VGND VPWR VPWR sky130_fd_sc_hd__fill_1
XFILLER_59_240 VGND VGND VPWR VPWR sky130_fd_sc_hd__decap_3
XFILLER_47_402 VGND VGND VPWR VPWR sky130_fd_sc_hd__fill_2
XFILLER_59_273 VGND VGND VPWR VPWR sky130_fd_sc_hd__decap_3
XFILLER_86_67 VGND VGND VPWR VPWR sky130_fd_sc_hd__decap_3
XFILLER_101_381 VGND VGND VPWR VPWR sky130_fd_sc_hd__decap_3
XFILLER_19_50 VGND VGND VPWR VPWR sky130_fd_sc_hd__decap_3
XFILLER_47_435 VGND VGND VPWR VPWR sky130_fd_sc_hd__fill_2
XFILLER_47_446 VGND VGND VPWR VPWR sky130_fd_sc_hd__fill_2
XFILLER_59_284 VGND VGND VPWR VPWR sky130_fd_sc_hd__decap_3
XTAP_TAPCELL_ROW_58_942 VGND VPWR sky130_fd_sc_hd__tapvpwrvgnd_1
XFILLER_19_159 VGND VGND VPWR VPWR sky130_fd_sc_hd__decap_3
XFILLER_47_457 VGND VGND VPWR VPWR sky130_fd_sc_hd__fill_1
XFILLER_74_265 VGND VGND VPWR VPWR sky130_fd_sc_hd__decap_3
XTAP_TAPCELL_ROW_58_953 VGND VPWR sky130_fd_sc_hd__tapvpwrvgnd_1
XTAP_TAPCELL_ROW_2_280 VGND VPWR sky130_fd_sc_hd__tapvpwrvgnd_1
XFILLER_27_181 VGND VGND VPWR VPWR sky130_fd_sc_hd__decap_3
XFILLER_35_60 VGND VGND VPWR VPWR sky130_fd_sc_hd__fill_2
XFILLER_43_641 VGND VGND VPWR VPWR sky130_fd_sc_hd__decap_3
XFILLER_55_490 VGND VGND VPWR VPWR sky130_fd_sc_hd__fill_2
XTAP_TAPCELL_ROW_83_1244 VGND VPWR sky130_fd_sc_hd__tapvpwrvgnd_1
XPHY_EDGE_ROW_106_Left_223 VGND VGND VPWR VPWR sky130_fd_sc_hd__decap_3
XFILLER_30_302 VGND VGND VPWR VPWR sky130_fd_sc_hd__decap_3
XFILLER_43_685 VGND VGND VPWR VPWR sky130_fd_sc_hd__decap_3
XFILLER_70_460 VGND VGND VPWR VPWR sky130_fd_sc_hd__decap_3
XFILLER_51_70 VGND VGND VPWR VPWR sky130_fd_sc_hd__decap_3
XFILLER_109_470 VGND VGND VPWR VPWR sky130_fd_sc_hd__decap_3
XFILLER_109_481 VGND VGND VPWR VPWR sky130_fd_sc_hd__decap_3
X_3360_ _3353_/A _3362_/A _3369_/A VGND VGND VPWR VPWR _3386_/B sky130_fd_sc_hd__mux2_2
XTAP_TAPCELL_ROW_94_1384 VGND VPWR sky130_fd_sc_hd__tapvpwrvgnd_1
XPHY_EDGE_ROW_115_Left_232 VGND VGND VPWR VPWR sky130_fd_sc_hd__decap_3
XFILLER_112_613 VGND VGND VPWR VPWR sky130_fd_sc_hd__decap_3
XFILLER_97_302 VGND VGND VPWR VPWR sky130_fd_sc_hd__decap_3
XFILLER_111_134 VGND VGND VPWR VPWR sky130_fd_sc_hd__decap_3
XFILLER_112_657 VGND VGND VPWR VPWR sky130_fd_sc_hd__decap_3
XFILLER_97_357 VGND VGND VPWR VPWR sky130_fd_sc_hd__fill_2
X_5030_ _6989_/Q _5044_/A VGND VGND VPWR VPWR _6989_/D sky130_fd_sc_hd__xor2_2
XFILLER_111_178 VGND VGND VPWR VPWR sky130_fd_sc_hd__decap_3
XFILLER_25_3 VGND VGND VPWR VPWR sky130_fd_sc_hd__decap_3
XFILLER_38_413 VGND VGND VPWR VPWR sky130_fd_sc_hd__decap_3
XFILLER_85_519 VGND VGND VPWR VPWR sky130_fd_sc_hd__decap_3
XFILLER_97_379 VGND VGND VPWR VPWR sky130_fd_sc_hd__decap_3
Xhold1209 _7168_/Q VGND VGND VPWR VPWR _5325_/A0 sky130_fd_sc_hd__dlygate4sd3_1
XFILLER_53_405 VGND VGND VPWR VPWR sky130_fd_sc_hd__fill_1
X_6981_ _7330_/CLK _6981_/D _6261_/Y VGND VGND VPWR VPWR _6981_/Q sky130_fd_sc_hd__dfrtp_2
XFILLER_19_682 VGND VGND VPWR VPWR sky130_fd_sc_hd__fill_2
XFILLER_65_287 VGND VGND VPWR VPWR sky130_fd_sc_hd__decap_3
XFILLER_80_213 VGND VGND VPWR VPWR sky130_fd_sc_hd__decap_3
XTAP_TAPCELL_ROW_0_239 VGND VPWR sky130_fd_sc_hd__tapvpwrvgnd_1
XFILLER_18_192 VGND VGND VPWR VPWR sky130_fd_sc_hd__decap_3
XFILLER_34_641 VGND VGND VPWR VPWR sky130_fd_sc_hd__decap_3
XFILLER_21_302 VGND VGND VPWR VPWR sky130_fd_sc_hd__decap_3
XFILLER_33_184 VGND VGND VPWR VPWR sky130_fd_sc_hd__decap_3
XFILLER_61_482 VGND VGND VPWR VPWR sky130_fd_sc_hd__decap_3
X_4814_ _4814_/A _4814_/B VGND VGND VPWR VPWR _4814_/Y sky130_fd_sc_hd__nor2_2
X_4745_ _4745_/A VGND VGND VPWR VPWR _4745_/Y sky130_fd_sc_hd__inv_2
XTAP_TAPCELL_ROW_103_1491 VGND VPWR sky130_fd_sc_hd__tapvpwrvgnd_1
XFILLER_31_18 VGND VGND VPWR VPWR sky130_fd_sc_hd__fill_1
XFILLER_31_29 VGND VGND VPWR VPWR sky130_fd_sc_hd__decap_3
X_4676_ _5648_/A _5067_/B _6985_/Q _6986_/Q _6987_/Q VGND VGND VPWR VPWR _5045_/B
+ sky130_fd_sc_hd__o2111a_2
X_7395_ _7403_/CLK _7395_/D _6675_/Y VGND VGND VPWR VPWR _7395_/Q sky130_fd_sc_hd__dfrtp_2
X_6415_ _6548_/A VGND VGND VPWR VPWR _6415_/Y sky130_fd_sc_hd__inv_2
X_3627_ _3746_/A _3746_/B _3733_/C VGND VGND VPWR VPWR _5660_/A sky130_fd_sc_hd__and3_2
X_6346_ _6540_/A VGND VGND VPWR VPWR _6346_/Y sky130_fd_sc_hd__inv_2
X_3558_ _7061_/Q _3577_/B VGND VGND VPWR VPWR _3558_/X sky130_fd_sc_hd__or2_2
XFILLER_102_112 VGND VGND VPWR VPWR sky130_fd_sc_hd__decap_3
XFILLER_103_657 VGND VGND VPWR VPWR sky130_fd_sc_hd__decap_3
XFILLER_88_368 VGND VGND VPWR VPWR sky130_fd_sc_hd__decap_3
X_6277_ _6280_/A VGND VGND VPWR VPWR _6277_/Y sky130_fd_sc_hd__inv_2
X_3489_ _7311_/Q _4471_/S _4346_/B1 _7343_/Q _3488_/X VGND VGND VPWR VPWR _3489_/X
+ sky130_fd_sc_hd__a221o_2
XFILLER_103_679 VGND VGND VPWR VPWR sky130_fd_sc_hd__decap_3
XFILLER_29_402 VGND VGND VPWR VPWR sky130_fd_sc_hd__decap_3
X_5228_ _5238_/B VGND VGND VPWR VPWR _5229_/B sky130_fd_sc_hd__inv_2
XFILLER_29_446 VGND VGND VPWR VPWR sky130_fd_sc_hd__fill_2
XFILLER_84_530 VGND VGND VPWR VPWR sky130_fd_sc_hd__fill_2
X_5159_ _5159_/A0 _4470_/X _5159_/S VGND VGND VPWR VPWR _7247_/D sky130_fd_sc_hd__mux2_2
XFILLER_56_232 VGND VGND VPWR VPWR sky130_fd_sc_hd__decap_3
XFILLER_56_265 VGND VGND VPWR VPWR sky130_fd_sc_hd__decap_3
XFILLER_112_32 VGND VGND VPWR VPWR sky130_fd_sc_hd__decap_3
XFILLER_16_118 VGND VGND VPWR VPWR sky130_fd_sc_hd__decap_3
XFILLER_56_298 VGND VGND VPWR VPWR sky130_fd_sc_hd__decap_3
XTAP_TAPCELL_ROW_55_912 VGND VPWR sky130_fd_sc_hd__tapvpwrvgnd_1
XFILLER_112_65 VGND VGND VPWR VPWR sky130_fd_sc_hd__decap_3
XFILLER_25_641 VGND VGND VPWR VPWR sky130_fd_sc_hd__decap_3
XFILLER_71_246 VGND VGND VPWR VPWR sky130_fd_sc_hd__decap_3
Xclkbuf_leaf_36_clk clkload0/A VGND VGND VPWR VPWR _7387_/CLK sky130_fd_sc_hd__clkbuf_16
XFILLER_71_268 VGND VGND VPWR VPWR sky130_fd_sc_hd__decap_3
XFILLER_12_324 VGND VGND VPWR VPWR sky130_fd_sc_hd__decap_3
XFILLER_24_173 VGND VGND VPWR VPWR sky130_fd_sc_hd__decap_3
XFILLER_72_69 VGND VGND VPWR VPWR sky130_fd_sc_hd__decap_3
XFILLER_12_357 VGND VGND VPWR VPWR sky130_fd_sc_hd__decap_3
XFILLER_12_368 VGND VGND VPWR VPWR sky130_fd_sc_hd__fill_1
XFILLER_40_677 VGND VGND VPWR VPWR sky130_fd_sc_hd__decap_3
XFILLER_8_306 VGND VGND VPWR VPWR sky130_fd_sc_hd__fill_2
XFILLER_4_501 VGND VGND VPWR VPWR sky130_fd_sc_hd__decap_3
XFILLER_106_440 VGND VGND VPWR VPWR sky130_fd_sc_hd__decap_3
XFILLER_4_567 VGND VGND VPWR VPWR sky130_fd_sc_hd__decap_3
XFILLER_106_462 VGND VGND VPWR VPWR sky130_fd_sc_hd__decap_3
XFILLER_4_589 VGND VGND VPWR VPWR sky130_fd_sc_hd__decap_3
XFILLER_97_33 VGND VGND VPWR VPWR sky130_fd_sc_hd__decap_3
XFILLER_97_55 VGND VGND VPWR VPWR sky130_fd_sc_hd__fill_1
XFILLER_79_346 VGND VGND VPWR VPWR sky130_fd_sc_hd__fill_2
XFILLER_79_368 VGND VGND VPWR VPWR sky130_fd_sc_hd__fill_1
XFILLER_102_690 VGND VGND VPWR VPWR sky130_fd_sc_hd__fill_2
XFILLER_11_9 VGND VGND VPWR VPWR sky130_fd_sc_hd__decap_3
XFILLER_35_405 VGND VGND VPWR VPWR sky130_fd_sc_hd__fill_2
XFILLER_75_541 VGND VGND VPWR VPWR sky130_fd_sc_hd__fill_1
XFILLER_47_298 VGND VGND VPWR VPWR sky130_fd_sc_hd__decap_3
XFILLER_62_224 VGND VGND VPWR VPWR sky130_fd_sc_hd__decap_3
XFILLER_90_533 VGND VGND VPWR VPWR sky130_fd_sc_hd__decap_3
XFILLER_35_449 VGND VGND VPWR VPWR sky130_fd_sc_hd__decap_3
XFILLER_46_81 VGND VGND VPWR VPWR sky130_fd_sc_hd__decap_3
XFILLER_62_246 VGND VGND VPWR VPWR sky130_fd_sc_hd__decap_3
Xclkbuf_leaf_27_clk clkbuf_3_2__f_clk/X VGND VGND VPWR VPWR _6929_/CLK sky130_fd_sc_hd__clkbuf_16
XFILLER_43_471 VGND VGND VPWR VPWR sky130_fd_sc_hd__decap_3
XFILLER_50_408 VGND VGND VPWR VPWR sky130_fd_sc_hd__decap_3
XFILLER_62_279 VGND VGND VPWR VPWR sky130_fd_sc_hd__decap_3
XFILLER_15_184 VGND VGND VPWR VPWR sky130_fd_sc_hd__decap_3
XFILLER_30_121 VGND VGND VPWR VPWR sky130_fd_sc_hd__decap_3
XFILLER_31_644 VGND VGND VPWR VPWR sky130_fd_sc_hd__decap_3
XFILLER_94_6 VGND VGND VPWR VPWR sky130_fd_sc_hd__decap_3
XFILLER_62_80 VGND VGND VPWR VPWR sky130_fd_sc_hd__decap_3
XFILLER_62_91 VGND VGND VPWR VPWR sky130_fd_sc_hd__decap_3
XFILLER_30_176 VGND VGND VPWR VPWR sky130_fd_sc_hd__decap_3
XFILLER_7_42 VGND VGND VPWR VPWR sky130_fd_sc_hd__decap_3
X_4530_ _4530_/A0 _7282_/Q _4530_/S VGND VGND VPWR VPWR _7314_/D sky130_fd_sc_hd__mux2_2
XTAP_TAPCELL_ROW_96_1402 VGND VPWR sky130_fd_sc_hd__tapvpwrvgnd_1
XFILLER_116_237 VGND VGND VPWR VPWR sky130_fd_sc_hd__decap_3
XFILLER_7_75 VGND VGND VPWR VPWR sky130_fd_sc_hd__decap_3
X_7180_ _7372_/CLK _7180_/D _6460_/Y VGND VGND VPWR VPWR _7180_/Q sky130_fd_sc_hd__dfrtp_2
X_3412_ _7187_/Q _3996_/S _4332_/B1 _7379_/Q VGND VGND VPWR VPWR _3412_/X sky130_fd_sc_hd__a22o_2
X_4392_ _7369_/Q _4435_/B1 _4434_/B1 _7145_/Q _4391_/X VGND VGND VPWR VPWR _4392_/X
+ sky130_fd_sc_hd__a221o_2
XTAP_TAPCELL_ROW_5_309 VGND VPWR sky130_fd_sc_hd__tapvpwrvgnd_1
XFILLER_98_666 VGND VGND VPWR VPWR sky130_fd_sc_hd__decap_3
XFILLER_112_454 VGND VGND VPWR VPWR sky130_fd_sc_hd__decap_3
Xhold1006 _7205_/Q VGND VGND VPWR VPWR _5249_/A0 sky130_fd_sc_hd__dlygate4sd3_1
XFILLER_85_327 VGND VGND VPWR VPWR sky130_fd_sc_hd__decap_3
XFILLER_85_349 VGND VGND VPWR VPWR sky130_fd_sc_hd__decap_3
Xhold1017 _7214_/Q VGND VGND VPWR VPWR _5232_/A0 sky130_fd_sc_hd__dlygate4sd3_1
Xhold1028 _7237_/Q VGND VGND VPWR VPWR _5182_/A sky130_fd_sc_hd__dlygate4sd3_1
Xhold1039 _7279_/Q VGND VGND VPWR VPWR _4603_/A1 sky130_fd_sc_hd__dlygate4sd3_1
XFILLER_38_232 VGND VGND VPWR VPWR sky130_fd_sc_hd__fill_1
XFILLER_38_243 VGND VGND VPWR VPWR sky130_fd_sc_hd__decap_3
XFILLER_26_18 VGND VGND VPWR VPWR sky130_fd_sc_hd__decap_3
XFILLER_26_29 VGND VGND VPWR VPWR sky130_fd_sc_hd__decap_3
XFILLER_26_416 VGND VGND VPWR VPWR sky130_fd_sc_hd__decap_3
XFILLER_26_427 VGND VGND VPWR VPWR sky130_fd_sc_hd__decap_3
XFILLER_38_265 VGND VGND VPWR VPWR sky130_fd_sc_hd__decap_3
XFILLER_38_298 VGND VGND VPWR VPWR sky130_fd_sc_hd__decap_3
XFILLER_81_511 VGND VGND VPWR VPWR sky130_fd_sc_hd__decap_3
XFILLER_53_246 VGND VGND VPWR VPWR sky130_fd_sc_hd__decap_3
XFILLER_93_393 VGND VGND VPWR VPWR sky130_fd_sc_hd__decap_3
Xclkbuf_leaf_18_clk clkbuf_3_6__f_clk/X VGND VGND VPWR VPWR _7005_/CLK sky130_fd_sc_hd__clkbuf_16
X_6964_ _6964_/CLK _6964_/D VGND VGND VPWR VPWR _6964_/Q sky130_fd_sc_hd__dfxtp_2
XPHY_EDGE_ROW_5_Right_5 VGND VGND VPWR VPWR sky130_fd_sc_hd__decap_3
XFILLER_22_600 VGND VGND VPWR VPWR sky130_fd_sc_hd__decap_3
XFILLER_53_279 VGND VGND VPWR VPWR sky130_fd_sc_hd__fill_1
XFILLER_81_599 VGND VGND VPWR VPWR sky130_fd_sc_hd__decap_3
X_6895_ _6959_/CLK _6895_/D VGND VGND VPWR VPWR _6895_/Q sky130_fd_sc_hd__dfxtp_2
XFILLER_21_143 VGND VGND VPWR VPWR sky130_fd_sc_hd__decap_3
XFILLER_22_655 VGND VGND VPWR VPWR sky130_fd_sc_hd__fill_2
XFILLER_61_290 VGND VGND VPWR VPWR sky130_fd_sc_hd__decap_3
XFILLER_21_187 VGND VGND VPWR VPWR sky130_fd_sc_hd__decap_3
XTAP_TAPCELL_ROW_60_970 VGND VPWR sky130_fd_sc_hd__tapvpwrvgnd_1
X_4728_ _4728_/A _4728_/B VGND VGND VPWR VPWR _4729_/B sky130_fd_sc_hd__nand2_2
X_4659_ _4814_/A _4457_/X _4658_/Y _4852_/A _4040_/Y VGND VGND VPWR VPWR _4659_/X
+ sky130_fd_sc_hd__o2111a_2
XTAP_TAPCELL_ROW_116_1660 VGND VPWR sky130_fd_sc_hd__tapvpwrvgnd_1
XFILLER_107_32 VGND VGND VPWR VPWR sky130_fd_sc_hd__decap_3
X_7378_ _7384_/CLK _7378_/D _6658_/Y VGND VGND VPWR VPWR _7378_/Q sky130_fd_sc_hd__dfrtp_2
Xhold840 _6942_/Q VGND VGND VPWR VPWR _6942_/D sky130_fd_sc_hd__dlygate4sd3_1
Xhold851 _7113_/Q VGND VGND VPWR VPWR _7113_/D sky130_fd_sc_hd__dlygate4sd3_1
Xhold862 _7098_/Q VGND VGND VPWR VPWR _7098_/D sky130_fd_sc_hd__dlygate4sd3_1
Xhold873 _7108_/Q VGND VGND VPWR VPWR _7108_/D sky130_fd_sc_hd__dlygate4sd3_1
Xmax_cap570 _6606_/A VGND VGND VPWR VPWR _6576_/A sky130_fd_sc_hd__clkbuf_2
XFILLER_103_443 VGND VGND VPWR VPWR sky130_fd_sc_hd__fill_2
XFILLER_115_281 VGND VGND VPWR VPWR sky130_fd_sc_hd__decap_3
XFILLER_1_559 VGND VGND VPWR VPWR sky130_fd_sc_hd__fill_1
XFILLER_88_132 VGND VGND VPWR VPWR sky130_fd_sc_hd__decap_3
XFILLER_89_644 VGND VGND VPWR VPWR sky130_fd_sc_hd__decap_3
XFILLER_89_666 VGND VGND VPWR VPWR sky130_fd_sc_hd__decap_3
Xhold884 _7086_/Q VGND VGND VPWR VPWR _7086_/D sky130_fd_sc_hd__dlygate4sd3_1
Xhold895 _7095_/Q VGND VGND VPWR VPWR _7095_/D sky130_fd_sc_hd__dlygate4sd3_1
X_6329_ _6616_/A VGND VGND VPWR VPWR _6329_/Y sky130_fd_sc_hd__inv_2
XFILLER_107_87 VGND VGND VPWR VPWR sky130_fd_sc_hd__decap_3
XFILLER_67_36 VGND VGND VPWR VPWR sky130_fd_sc_hd__decap_3
XFILLER_88_165 VGND VGND VPWR VPWR sky130_fd_sc_hd__decap_3
XFILLER_89_688 VGND VGND VPWR VPWR sky130_fd_sc_hd__decap_3
XFILLER_57_530 VGND VGND VPWR VPWR sky130_fd_sc_hd__fill_1
XFILLER_67_69 VGND VGND VPWR VPWR sky130_fd_sc_hd__decap_3
XFILLER_76_327 VGND VGND VPWR VPWR sky130_fd_sc_hd__decap_3
XFILLER_29_254 VGND VGND VPWR VPWR sky130_fd_sc_hd__decap_3
XFILLER_29_276 VGND VGND VPWR VPWR sky130_fd_sc_hd__decap_3
XFILLER_29_287 VGND VGND VPWR VPWR sky130_fd_sc_hd__decap_3
XFILLER_17_449 VGND VGND VPWR VPWR sky130_fd_sc_hd__decap_3
XFILLER_72_555 VGND VGND VPWR VPWR sky130_fd_sc_hd__decap_3
XFILLER_83_57 VGND VGND VPWR VPWR sky130_fd_sc_hd__decap_3
XTAP_TAPCELL_ROW_67_1058 VGND VPWR sky130_fd_sc_hd__tapvpwrvgnd_1
XFILLER_16_62 VGND VGND VPWR VPWR sky130_fd_sc_hd__decap_3
XTAP_TAPCELL_ROW_80_1214 VGND VPWR sky130_fd_sc_hd__tapvpwrvgnd_1
XFILLER_40_452 VGND VGND VPWR VPWR sky130_fd_sc_hd__decap_3
XFILLER_8_103 VGND VGND VPWR VPWR sky130_fd_sc_hd__fill_2
XTAP_TAPCELL_ROW_30_609 VGND VPWR sky130_fd_sc_hd__tapvpwrvgnd_1
XFILLER_9_615 VGND VGND VPWR VPWR sky130_fd_sc_hd__fill_1
XFILLER_13_688 VGND VGND VPWR VPWR sky130_fd_sc_hd__decap_3
XFILLER_32_50 VGND VGND VPWR VPWR sky130_fd_sc_hd__decap_3
XFILLER_32_83 VGND VGND VPWR VPWR sky130_fd_sc_hd__fill_1
XFILLER_8_147 VGND VGND VPWR VPWR sky130_fd_sc_hd__decap_3
XTAP_TAPCELL_ROW_10_377 VGND VPWR sky130_fd_sc_hd__tapvpwrvgnd_1
XTAP_TAPCELL_ROW_10_366 VGND VPWR sky130_fd_sc_hd__tapvpwrvgnd_1
XFILLER_59_9 VGND VGND VPWR VPWR sky130_fd_sc_hd__fill_2
XTAP_TAPCELL_ROW_78_1187 VGND VPWR sky130_fd_sc_hd__tapvpwrvgnd_1
XFILLER_99_419 VGND VGND VPWR VPWR sky130_fd_sc_hd__decap_3
XFILLER_106_281 VGND VGND VPWR VPWR sky130_fd_sc_hd__fill_2
XFILLER_106_292 VGND VGND VPWR VPWR sky130_fd_sc_hd__decap_3
XTAP_TAPCELL_ROW_91_1343 VGND VPWR sky130_fd_sc_hd__tapvpwrvgnd_1
XFILLER_79_143 VGND VGND VPWR VPWR sky130_fd_sc_hd__decap_3
XFILLER_95_614 VGND VGND VPWR VPWR sky130_fd_sc_hd__fill_2
XFILLER_0_581 VGND VGND VPWR VPWR sky130_fd_sc_hd__decap_3
XFILLER_79_187 VGND VGND VPWR VPWR sky130_fd_sc_hd__decap_3
XFILLER_94_102 VGND VGND VPWR VPWR sky130_fd_sc_hd__decap_3
XTAP_TAPCELL_ROW_38_709 VGND VPWR sky130_fd_sc_hd__tapvpwrvgnd_1
XFILLER_35_202 VGND VGND VPWR VPWR sky130_fd_sc_hd__fill_2
XFILLER_35_235 VGND VGND VPWR VPWR sky130_fd_sc_hd__decap_3
XFILLER_75_393 VGND VGND VPWR VPWR sky130_fd_sc_hd__decap_3
XFILLER_35_268 VGND VGND VPWR VPWR sky130_fd_sc_hd__decap_3
XFILLER_90_363 VGND VGND VPWR VPWR sky130_fd_sc_hd__fill_1
XTAP_TAPCELL_ROW_18_466 VGND VPWR sky130_fd_sc_hd__tapvpwrvgnd_1
XFILLER_73_90 VGND VGND VPWR VPWR sky130_fd_sc_hd__decap_3
XFILLER_92_3 VGND VGND VPWR VPWR sky130_fd_sc_hd__decap_3
X_6680_ _6684_/A VGND VGND VPWR VPWR _6680_/Y sky130_fd_sc_hd__inv_2
X_3892_ _6771_/Q _3892_/A2 _3892_/B1 _6765_/Q VGND VGND VPWR VPWR _3892_/X sky130_fd_sc_hd__a22o_2
XTAP_TAPCELL_ROW_100_1450 VGND VPWR sky130_fd_sc_hd__tapvpwrvgnd_1
XFILLER_8_670 VGND VGND VPWR VPWR sky130_fd_sc_hd__decap_3
X_7301_ _7365_/CLK _7301_/D _6581_/Y VGND VGND VPWR VPWR _7301_/Q sky130_fd_sc_hd__dfrtp_2
X_4513_ _4513_/A0 _7291_/Q _4530_/S VGND VGND VPWR VPWR _7323_/D sky130_fd_sc_hd__mux2_2
X_7232_ _7397_/CLK _7232_/D _6512_/Y VGND VGND VPWR VPWR _7232_/Q sky130_fd_sc_hd__dfrtp_2
XFILLER_104_218 VGND VGND VPWR VPWR sky130_fd_sc_hd__fill_1
XFILLER_104_229 VGND VGND VPWR VPWR sky130_fd_sc_hd__fill_2
Xclkbuf_leaf_7_clk clkload2/A VGND VGND VPWR VPWR _7363_/CLK sky130_fd_sc_hd__clkbuf_16
X_4444_ _4396_/A _4444_/B VGND VGND VPWR VPWR _4444_/X sky130_fd_sc_hd__and2b_2
X_7163_ _7322_/CLK _7163_/D _6443_/Y VGND VGND VPWR VPWR _7163_/Q sky130_fd_sc_hd__dfrtp_2
X_4375_ _5003_/A _4374_/X _4988_/A VGND VGND VPWR VPWR _4375_/X sky130_fd_sc_hd__o21ba_2
XFILLER_58_305 VGND VGND VPWR VPWR sky130_fd_sc_hd__decap_3
XFILLER_86_603 VGND VGND VPWR VPWR sky130_fd_sc_hd__decap_3
X_7094_ clkload9/A _7094_/D _6374_/Y VGND VGND VPWR VPWR _7094_/Q sky130_fd_sc_hd__dfrtp_2
X_3326_ _3326_/A _3326_/B VGND VGND VPWR VPWR _5238_/B sky130_fd_sc_hd__nor2_2
XFILLER_112_273 VGND VGND VPWR VPWR sky130_fd_sc_hd__decap_3
XFILLER_58_327 VGND VGND VPWR VPWR sky130_fd_sc_hd__decap_3
XFILLER_58_338 VGND VGND VPWR VPWR sky130_fd_sc_hd__decap_3
XFILLER_98_485 VGND VGND VPWR VPWR sky130_fd_sc_hd__decap_3
XFILLER_85_146 VGND VGND VPWR VPWR sky130_fd_sc_hd__decap_3
XFILLER_39_585 VGND VGND VPWR VPWR sky130_fd_sc_hd__decap_3
XFILLER_14_408 VGND VGND VPWR VPWR sky130_fd_sc_hd__fill_1
XFILLER_26_268 VGND VGND VPWR VPWR sky130_fd_sc_hd__decap_3
XFILLER_53_27 VGND VGND VPWR VPWR sky130_fd_sc_hd__decap_3
XFILLER_54_566 VGND VGND VPWR VPWR sky130_fd_sc_hd__decap_3
XFILLER_81_352 VGND VGND VPWR VPWR sky130_fd_sc_hd__decap_3
XFILLER_81_385 VGND VGND VPWR VPWR sky130_fd_sc_hd__decap_3
XFILLER_81_396 VGND VGND VPWR VPWR sky130_fd_sc_hd__decap_3
X_6947_ _6976_/CLK _6947_/D VGND VGND VPWR VPWR _6947_/Q sky130_fd_sc_hd__dfxtp_2
XFILLER_22_430 VGND VGND VPWR VPWR sky130_fd_sc_hd__decap_3
X_6878_ _6931_/CLK _6878_/D VGND VGND VPWR VPWR _6878_/Q sky130_fd_sc_hd__dfxtp_2
XFILLER_10_658 VGND VGND VPWR VPWR sky130_fd_sc_hd__decap_3
XFILLER_108_524 VGND VGND VPWR VPWR sky130_fd_sc_hd__decap_3
XFILLER_5_128 VGND VGND VPWR VPWR sky130_fd_sc_hd__fill_2
XFILLER_5_139 VGND VGND VPWR VPWR sky130_fd_sc_hd__decap_3
XTAP_TAPCELL_ROW_114_1619 VGND VPWR sky130_fd_sc_hd__tapvpwrvgnd_1
XFILLER_1_334 VGND VGND VPWR VPWR sky130_fd_sc_hd__fill_2
XFILLER_78_35 VGND VGND VPWR VPWR sky130_fd_sc_hd__decap_3
Xhold670 _6929_/Q VGND VGND VPWR VPWR _6929_/D sky130_fd_sc_hd__dlygate4sd3_1
Xhold681 _6928_/Q VGND VGND VPWR VPWR _6928_/D sky130_fd_sc_hd__dlygate4sd3_1
XFILLER_103_251 VGND VGND VPWR VPWR sky130_fd_sc_hd__decap_3
XFILLER_77_603 VGND VGND VPWR VPWR sky130_fd_sc_hd__decap_3
XFILLER_78_79 VGND VGND VPWR VPWR sky130_fd_sc_hd__decap_3
Xhold692 _6824_/Q VGND VGND VPWR VPWR _6824_/D sky130_fd_sc_hd__dlygate4sd3_1
XFILLER_103_284 VGND VGND VPWR VPWR sky130_fd_sc_hd__fill_2
XFILLER_1_378 VGND VGND VPWR VPWR sky130_fd_sc_hd__decap_3
XFILLER_76_157 VGND VGND VPWR VPWR sky130_fd_sc_hd__decap_3
XFILLER_94_12 VGND VGND VPWR VPWR sky130_fd_sc_hd__decap_3
XFILLER_94_45 VGND VGND VPWR VPWR sky130_fd_sc_hd__decap_3
XFILLER_17_202 VGND VGND VPWR VPWR sky130_fd_sc_hd__fill_2
XFILLER_45_511 VGND VGND VPWR VPWR sky130_fd_sc_hd__fill_1
XFILLER_91_116 VGND VGND VPWR VPWR sky130_fd_sc_hd__decap_3
XFILLER_92_628 VGND VGND VPWR VPWR sky130_fd_sc_hd__decap_3
XFILLER_94_67 VGND VGND VPWR VPWR sky130_fd_sc_hd__decap_3
XFILLER_17_213 VGND VGND VPWR VPWR sky130_fd_sc_hd__decap_3
XFILLER_17_246 VGND VGND VPWR VPWR sky130_fd_sc_hd__decap_3
XFILLER_85_691 VGND VGND VPWR VPWR sky130_fd_sc_hd__fill_1
XFILLER_91_149 VGND VGND VPWR VPWR sky130_fd_sc_hd__decap_3
XFILLER_17_279 VGND VGND VPWR VPWR sky130_fd_sc_hd__fill_1
XFILLER_72_352 VGND VGND VPWR VPWR sky130_fd_sc_hd__fill_1
XFILLER_32_227 VGND VGND VPWR VPWR sky130_fd_sc_hd__fill_2
XFILLER_13_430 VGND VGND VPWR VPWR sky130_fd_sc_hd__fill_1
XFILLER_13_452 VGND VGND VPWR VPWR sky130_fd_sc_hd__decap_3
XTAP_TAPCELL_ROW_43_767 VGND VPWR sky130_fd_sc_hd__tapvpwrvgnd_1
XTAP_TAPCELL_ROW_15_436 VGND VPWR sky130_fd_sc_hd__tapvpwrvgnd_1
XFILLER_43_60 VGND VGND VPWR VPWR sky130_fd_sc_hd__decap_3
XFILLER_43_93 VGND VGND VPWR VPWR sky130_fd_sc_hd__decap_3
XFILLER_40_282 VGND VGND VPWR VPWR sky130_fd_sc_hd__fill_1
XFILLER_5_640 VGND VGND VPWR VPWR sky130_fd_sc_hd__decap_3
XFILLER_4_150 VGND VGND VPWR VPWR sky130_fd_sc_hd__decap_3
XFILLER_5_673 VGND VGND VPWR VPWR sky130_fd_sc_hd__decap_3
XFILLER_4_194 VGND VGND VPWR VPWR sky130_fd_sc_hd__fill_2
XFILLER_4_21 VGND VGND VPWR VPWR sky130_fd_sc_hd__decap_3
XFILLER_4_32 VGND VGND VPWR VPWR sky130_fd_sc_hd__decap_3
XFILLER_4_65 VGND VGND VPWR VPWR sky130_fd_sc_hd__decap_3
XFILLER_68_614 VGND VGND VPWR VPWR sky130_fd_sc_hd__fill_1
X_4160_ _7297_/Q _4501_/S _4430_/B1 _7169_/Q _4159_/X VGND VGND VPWR VPWR _4160_/X
+ sky130_fd_sc_hd__a221o_2
XFILLER_67_113 VGND VGND VPWR VPWR sky130_fd_sc_hd__decap_3
XFILLER_68_625 VGND VGND VPWR VPWR sky130_fd_sc_hd__decap_3
XFILLER_95_422 VGND VGND VPWR VPWR sky130_fd_sc_hd__decap_3
XFILLER_67_135 VGND VGND VPWR VPWR sky130_fd_sc_hd__decap_3
XFILLER_95_455 VGND VGND VPWR VPWR sky130_fd_sc_hd__fill_1
X_4091_ _7110_/Q _4434_/A2 _4434_/B1 _7142_/Q _4090_/X VGND VGND VPWR VPWR _4091_/X
+ sky130_fd_sc_hd__a221o_2
XFILLER_55_308 VGND VGND VPWR VPWR sky130_fd_sc_hd__fill_2
XFILLER_95_488 VGND VGND VPWR VPWR sky130_fd_sc_hd__decap_3
XFILLER_63_330 VGND VGND VPWR VPWR sky130_fd_sc_hd__decap_3
XFILLER_82_127 VGND VGND VPWR VPWR sky130_fd_sc_hd__decap_3
XFILLER_63_352 VGND VGND VPWR VPWR sky130_fd_sc_hd__decap_3
XFILLER_91_661 VGND VGND VPWR VPWR sky130_fd_sc_hd__decap_3
Xplace330 _4195_/A2 VGND VGND VPWR VPWR _4434_/B1 sky130_fd_sc_hd__buf_2
X_6801_ _7005_/CLK _6801_/D VGND VGND VPWR VPWR _6801_/Q sky130_fd_sc_hd__dfxtp_2
XFILLER_23_216 VGND VGND VPWR VPWR sky130_fd_sc_hd__decap_3
XFILLER_63_385 VGND VGND VPWR VPWR sky130_fd_sc_hd__decap_3
Xplace363 _4305_/B VGND VGND VPWR VPWR _3577_/B sky130_fd_sc_hd__buf_2
Xplace352 _5080_/S VGND VGND VPWR VPWR _5028_/S sky130_fd_sc_hd__buf_2
Xplace341 _3526_/B VGND VGND VPWR VPWR _5114_/A sky130_fd_sc_hd__buf_2
X_4993_ _4620_/C _4991_/Y _4992_/Y VGND VGND VPWR VPWR _4993_/X sky130_fd_sc_hd__o21a_2
XFILLER_51_569 VGND VGND VPWR VPWR sky130_fd_sc_hd__decap_3
Xplace385 _5217_/B VGND VGND VPWR VPWR _5225_/B sky130_fd_sc_hd__buf_2
Xplace396 _7412_/A VGND VGND VPWR VPWR _5350_/S sky130_fd_sc_hd__buf_2
Xplace374 _4466_/A VGND VGND VPWR VPWR _3909_/A2 sky130_fd_sc_hd__buf_2
X_6732_ _6964_/CLK _6732_/D VGND VGND VPWR VPWR _6732_/Q sky130_fd_sc_hd__dfxtp_2
XFILLER_31_271 VGND VGND VPWR VPWR sky130_fd_sc_hd__fill_1
X_6663_ _6672_/A VGND VGND VPWR VPWR _6663_/Y sky130_fd_sc_hd__inv_2
X_3875_ _3875_/A1 _5138_/S _3874_/X VGND VGND VPWR VPWR _7383_/D sky130_fd_sc_hd__o21a_2
XFILLER_31_293 VGND VGND VPWR VPWR sky130_fd_sc_hd__decap_3
X_6594_ _6635_/A VGND VGND VPWR VPWR _6594_/Y sky130_fd_sc_hd__inv_2
XFILLER_105_505 VGND VGND VPWR VPWR sky130_fd_sc_hd__decap_3
XFILLER_2_109 VGND VGND VPWR VPWR sky130_fd_sc_hd__decap_3
XFILLER_105_549 VGND VGND VPWR VPWR sky130_fd_sc_hd__decap_3
X_7215_ _7279_/CLK _7215_/D _6495_/Y VGND VGND VPWR VPWR _7215_/Q sky130_fd_sc_hd__dfrtp_2
XFILLER_48_16 VGND VGND VPWR VPWR sky130_fd_sc_hd__decap_3
X_7146_ _7338_/CLK _7146_/D _6426_/Y VGND VGND VPWR VPWR _7146_/Q sky130_fd_sc_hd__dfrtp_2
XFILLER_113_582 VGND VGND VPWR VPWR sky130_fd_sc_hd__decap_3
XFILLER_59_647 VGND VGND VPWR VPWR sky130_fd_sc_hd__decap_3
X_4358_ _4367_/A _4367_/B _4367_/C VGND VGND VPWR VPWR _5072_/B sky130_fd_sc_hd__a21bo_2
XFILLER_100_221 VGND VGND VPWR VPWR sky130_fd_sc_hd__decap_3
XFILLER_100_243 VGND VGND VPWR VPWR sky130_fd_sc_hd__decap_3
X_7077_ _7266_/CLK _7077_/D _6357_/Y VGND VGND VPWR VPWR _7077_/Q sky130_fd_sc_hd__dfrtp_2
X_4289_ _4537_/C _4289_/B VGND VGND VPWR VPWR _4649_/A sky130_fd_sc_hd__nand2_2
X_3309_ _3371_/A _3365_/A _3362_/A VGND VGND VPWR VPWR _3383_/B sky130_fd_sc_hd__or3_4
XFILLER_104_44 VGND VGND VPWR VPWR sky130_fd_sc_hd__decap_3
XFILLER_58_168 VGND VGND VPWR VPWR sky130_fd_sc_hd__decap_3
XFILLER_73_116 VGND VGND VPWR VPWR sky130_fd_sc_hd__decap_3
XFILLER_86_477 VGND VGND VPWR VPWR sky130_fd_sc_hd__decap_3
XFILLER_100_287 VGND VGND VPWR VPWR sky130_fd_sc_hd__decap_3
XFILLER_104_66 VGND VGND VPWR VPWR sky130_fd_sc_hd__decap_3
XFILLER_104_88 VGND VGND VPWR VPWR sky130_fd_sc_hd__decap_3
XFILLER_39_393 VGND VGND VPWR VPWR sky130_fd_sc_hd__decap_3
XFILLER_64_15 VGND VGND VPWR VPWR sky130_fd_sc_hd__decap_3
XFILLER_66_190 VGND VGND VPWR VPWR sky130_fd_sc_hd__fill_1
XFILLER_67_691 VGND VGND VPWR VPWR sky130_fd_sc_hd__fill_1
XFILLER_73_127 VGND VGND VPWR VPWR sky130_fd_sc_hd__fill_1
XFILLER_73_149 VGND VGND VPWR VPWR sky130_fd_sc_hd__decap_3
XFILLER_54_352 VGND VGND VPWR VPWR sky130_fd_sc_hd__decap_3
XFILLER_64_59 VGND VGND VPWR VPWR sky130_fd_sc_hd__decap_3
XFILLER_82_672 VGND VGND VPWR VPWR sky130_fd_sc_hd__decap_3
XFILLER_14_227 VGND VGND VPWR VPWR sky130_fd_sc_hd__decap_3
XFILLER_54_374 VGND VGND VPWR VPWR sky130_fd_sc_hd__decap_3
XFILLER_81_160 VGND VGND VPWR VPWR sky130_fd_sc_hd__fill_2
XTAP_TAPCELL_ROW_64_1017 VGND VPWR sky130_fd_sc_hd__tapvpwrvgnd_1
Xfanout20 _6632_/A VGND VGND VPWR VPWR _6567_/A sky130_fd_sc_hd__buf_2
Xfanout31 fanout38/X VGND VGND VPWR VPWR _6638_/A sky130_fd_sc_hd__clkdlybuf4s25_1
XFILLER_80_47 VGND VGND VPWR VPWR sky130_fd_sc_hd__decap_3
Xfanout42 _6547_/A VGND VGND VPWR VPWR _6578_/A sky130_fd_sc_hd__buf_2
Xfanout53 _6674_/A VGND VGND VPWR VPWR _6672_/A sky130_fd_sc_hd__buf_2
Xfanout64 fanout72/X VGND VGND VPWR VPWR _6683_/A sky130_fd_sc_hd__clkdlybuf4s25_1
XTAP_TAPCELL_ROW_40_726 VGND VPWR sky130_fd_sc_hd__tapvpwrvgnd_1
XFILLER_13_41 VGND VGND VPWR VPWR sky130_fd_sc_hd__decap_3
XFILLER_22_293 VGND VGND VPWR VPWR sky130_fd_sc_hd__decap_3
XTAP_TAPCELL_ROW_40_737 VGND VPWR sky130_fd_sc_hd__tapvpwrvgnd_1
XFILLER_13_63 VGND VGND VPWR VPWR sky130_fd_sc_hd__decap_3
XFILLER_6_415 VGND VGND VPWR VPWR sky130_fd_sc_hd__decap_3
XFILLER_108_343 VGND VGND VPWR VPWR sky130_fd_sc_hd__decap_3
XFILLER_89_23 VGND VGND VPWR VPWR sky130_fd_sc_hd__decap_3
XFILLER_108_365 VGND VGND VPWR VPWR sky130_fd_sc_hd__decap_3
XFILLER_89_45 VGND VGND VPWR VPWR sky130_fd_sc_hd__decap_3
XTAP_TAPCELL_ROW_20_494 VGND VPWR sky130_fd_sc_hd__tapvpwrvgnd_1
XFILLER_2_621 VGND VGND VPWR VPWR sky130_fd_sc_hd__decap_3
XTAP_TAPCELL_ROW_75_1157 VGND VPWR sky130_fd_sc_hd__tapvpwrvgnd_1
XTAP_TAPCELL_ROW_75_1146 VGND VPWR sky130_fd_sc_hd__tapvpwrvgnd_1
XFILLER_111_508 VGND VGND VPWR VPWR sky130_fd_sc_hd__decap_3
XFILLER_1_131 VGND VGND VPWR VPWR sky130_fd_sc_hd__decap_3
XFILLER_2_654 VGND VGND VPWR VPWR sky130_fd_sc_hd__decap_3
XFILLER_2_687 VGND VGND VPWR VPWR sky130_fd_sc_hd__decap_3
XFILLER_49_113 VGND VGND VPWR VPWR sky130_fd_sc_hd__fill_2
XFILLER_49_135 VGND VGND VPWR VPWR sky130_fd_sc_hd__decap_3
XFILLER_77_455 VGND VGND VPWR VPWR sky130_fd_sc_hd__decap_3
XFILLER_65_617 VGND VGND VPWR VPWR sky130_fd_sc_hd__decap_3
XFILLER_77_488 VGND VGND VPWR VPWR sky130_fd_sc_hd__decap_3
XFILLER_92_414 VGND VGND VPWR VPWR sky130_fd_sc_hd__decap_3
XTAP_TAPCELL_ROW_48_826 VGND VPWR sky130_fd_sc_hd__tapvpwrvgnd_1
XFILLER_33_503 VGND VGND VPWR VPWR sky130_fd_sc_hd__fill_1
XFILLER_80_609 VGND VGND VPWR VPWR sky130_fd_sc_hd__decap_3
XFILLER_92_469 VGND VGND VPWR VPWR sky130_fd_sc_hd__decap_3
XFILLER_33_514 VGND VGND VPWR VPWR sky130_fd_sc_hd__fill_1
XFILLER_72_182 VGND VGND VPWR VPWR sky130_fd_sc_hd__decap_3
XTAP_TAPCELL_ROW_86_1286 VGND VPWR sky130_fd_sc_hd__tapvpwrvgnd_1
XTAP_TAPCELL_ROW_28_583 VGND VPWR sky130_fd_sc_hd__tapvpwrvgnd_1
XFILLER_60_333 VGND VGND VPWR VPWR sky130_fd_sc_hd__decap_3
XFILLER_60_377 VGND VGND VPWR VPWR sky130_fd_sc_hd__decap_3
XFILLER_13_293 VGND VGND VPWR VPWR sky130_fd_sc_hd__decap_3
XFILLER_9_231 VGND VGND VPWR VPWR sky130_fd_sc_hd__decap_3
XFILLER_9_275 VGND VGND VPWR VPWR sky130_fd_sc_hd__decap_3
Xclkload12 _7322_/CLK VGND VGND VPWR VPWR clkload12/X sky130_fd_sc_hd__clkbuf_8
Xclkload23 _7330_/CLK VGND VGND VPWR VPWR clkload23/Y sky130_fd_sc_hd__inv_4
Xclkload34 _7386_/CLK VGND VGND VPWR VPWR clkload34/X sky130_fd_sc_hd__clkbuf_1
X_3591_ _3591_/A _3591_/B _3591_/C _3586_/D VGND VGND VPWR VPWR _3591_/Y sky130_fd_sc_hd__nor4b_2
XFILLER_55_3 VGND VGND VPWR VPWR sky130_fd_sc_hd__decap_3
XFILLER_102_508 VGND VGND VPWR VPWR sky130_fd_sc_hd__decap_3
XFILLER_114_368 VGND VGND VPWR VPWR sky130_fd_sc_hd__fill_1
X_7000_ _7341_/CLK _7000_/D _6280_/Y VGND VGND VPWR VPWR _7000_/Q sky130_fd_sc_hd__dfrtp_2
X_4212_ _7324_/Q _3968_/S _5229_/C _7132_/Q VGND VGND VPWR VPWR _4212_/X sky130_fd_sc_hd__a22o_2
XFILLER_87_219 VGND VGND VPWR VPWR sky130_fd_sc_hd__decap_3
X_5192_ _5192_/A _5217_/B VGND VGND VPWR VPWR _7232_/D sky130_fd_sc_hd__and2_2
XFILLER_56_606 VGND VGND VPWR VPWR sky130_fd_sc_hd__decap_3
XFILLER_68_455 VGND VGND VPWR VPWR sky130_fd_sc_hd__decap_3
X_4143_ _4845_/A _4140_/X _4142_/X VGND VGND VPWR VPWR _4143_/X sky130_fd_sc_hd__a21o_2
XFILLER_110_574 VGND VGND VPWR VPWR sky130_fd_sc_hd__decap_3
XFILLER_55_116 VGND VGND VPWR VPWR sky130_fd_sc_hd__fill_1
XFILLER_56_639 VGND VGND VPWR VPWR sky130_fd_sc_hd__decap_3
XFILLER_68_477 VGND VGND VPWR VPWR sky130_fd_sc_hd__decap_3
X_4074_ _7083_/Q _4432_/A2 _4142_/A _4073_/X VGND VGND VPWR VPWR _4451_/A sky130_fd_sc_hd__o211ai_2
XFILLER_49_691 VGND VGND VPWR VPWR sky130_fd_sc_hd__fill_1
XFILLER_95_296 VGND VGND VPWR VPWR sky130_fd_sc_hd__decap_3
XFILLER_36_363 VGND VGND VPWR VPWR sky130_fd_sc_hd__fill_1
XFILLER_64_672 VGND VGND VPWR VPWR sky130_fd_sc_hd__decap_3
XFILLER_71_609 VGND VGND VPWR VPWR sky130_fd_sc_hd__decap_3
XFILLER_51_311 VGND VGND VPWR VPWR sky130_fd_sc_hd__fill_2
XFILLER_34_29 VGND VGND VPWR VPWR sky130_fd_sc_hd__decap_3
XFILLER_11_208 VGND VGND VPWR VPWR sky130_fd_sc_hd__decap_3
XFILLER_51_377 VGND VGND VPWR VPWR sky130_fd_sc_hd__fill_1
XFILLER_51_388 VGND VGND VPWR VPWR sky130_fd_sc_hd__fill_1
X_6715_ _7406_/CLK _6715_/D VGND VGND VPWR VPWR _6715_/Q sky130_fd_sc_hd__dfxtp_2
X_4976_ _6992_/Q _5001_/A _6993_/Q VGND VGND VPWR VPWR _4977_/B sky130_fd_sc_hd__a21oi_2
XFILLER_51_399 VGND VGND VPWR VPWR sky130_fd_sc_hd__decap_3
X_3927_ _3682_/A _3926_/X _5104_/A VGND VGND VPWR VPWR _3927_/X sky130_fd_sc_hd__a21o_2
Xclkload6 clkload6/A VGND VGND VPWR VPWR clkload6/Y sky130_fd_sc_hd__inv_4
X_6646_ _6684_/A VGND VGND VPWR VPWR _6646_/Y sky130_fd_sc_hd__inv_2
X_3858_ _6698_/Q _3925_/A2 _3925_/B1 _6876_/Q VGND VGND VPWR VPWR _3858_/X sky130_fd_sc_hd__a22o_2
X_6577_ _6642_/A VGND VGND VPWR VPWR _6577_/Y sky130_fd_sc_hd__inv_2
X_3789_ _3728_/Y _3781_/X _3783_/X _3725_/X _3788_/X VGND VGND VPWR VPWR _3789_/X
+ sky130_fd_sc_hd__a221o_2
XFILLER_105_324 VGND VGND VPWR VPWR sky130_fd_sc_hd__decap_3
XFILLER_3_429 VGND VGND VPWR VPWR sky130_fd_sc_hd__decap_3
XFILLER_59_26 VGND VGND VPWR VPWR sky130_fd_sc_hd__decap_3
XFILLER_59_48 VGND VGND VPWR VPWR sky130_fd_sc_hd__decap_3
Xoutput550 _6985_/Q VGND VGND VPWR VPWR pc_out[8] sky130_fd_sc_hd__clkdlybuf4s25_1
XFILLER_105_379 VGND VGND VPWR VPWR sky130_fd_sc_hd__decap_3
XFILLER_101_541 VGND VGND VPWR VPWR sky130_fd_sc_hd__decap_3
XFILLER_115_32 VGND VGND VPWR VPWR sky130_fd_sc_hd__decap_3
X_7129_ _7279_/CLK _7129_/D _6409_/Y VGND VGND VPWR VPWR _7129_/Q sky130_fd_sc_hd__dfrtp_2
XFILLER_101_574 VGND VGND VPWR VPWR sky130_fd_sc_hd__decap_3
XFILLER_115_87 VGND VGND VPWR VPWR sky130_fd_sc_hd__decap_3
XFILLER_47_617 VGND VGND VPWR VPWR sky130_fd_sc_hd__decap_3
XFILLER_59_466 VGND VGND VPWR VPWR sky130_fd_sc_hd__decap_3
XFILLER_75_25 VGND VGND VPWR VPWR sky130_fd_sc_hd__decap_3
XTAP_TAPCELL_ROW_70_1087 VGND VPWR sky130_fd_sc_hd__tapvpwrvgnd_1
XFILLER_75_69 VGND VGND VPWR VPWR sky130_fd_sc_hd__decap_3
XFILLER_15_503 VGND VGND VPWR VPWR sky130_fd_sc_hd__fill_1
XFILLER_27_330 VGND VGND VPWR VPWR sky130_fd_sc_hd__decap_3
XFILLER_27_341 VGND VGND VPWR VPWR sky130_fd_sc_hd__decap_3
XFILLER_39_190 VGND VGND VPWR VPWR sky130_fd_sc_hd__decap_3
XFILLER_55_650 VGND VGND VPWR VPWR sky130_fd_sc_hd__decap_3
XFILLER_27_374 VGND VGND VPWR VPWR sky130_fd_sc_hd__fill_1
XFILLER_27_396 VGND VGND VPWR VPWR sky130_fd_sc_hd__decap_3
XFILLER_42_300 VGND VGND VPWR VPWR sky130_fd_sc_hd__decap_3
XFILLER_61_119 VGND VGND VPWR VPWR sky130_fd_sc_hd__decap_3
XFILLER_82_480 VGND VGND VPWR VPWR sky130_fd_sc_hd__decap_3
XFILLER_42_344 VGND VGND VPWR VPWR sky130_fd_sc_hd__decap_3
XFILLER_54_193 VGND VGND VPWR VPWR sky130_fd_sc_hd__decap_3
XFILLER_70_631 VGND VGND VPWR VPWR sky130_fd_sc_hd__fill_2
XFILLER_91_57 VGND VGND VPWR VPWR sky130_fd_sc_hd__fill_2
XTAP_TAPCELL_ROW_53_884 VGND VPWR sky130_fd_sc_hd__tapvpwrvgnd_1
XTAP_TAPCELL_ROW_25_553 VGND VPWR sky130_fd_sc_hd__tapvpwrvgnd_1
XFILLER_42_399 VGND VGND VPWR VPWR sky130_fd_sc_hd__fill_1
XFILLER_24_95 VGND VGND VPWR VPWR sky130_fd_sc_hd__fill_1
XFILLER_109_641 VGND VGND VPWR VPWR sky130_fd_sc_hd__decap_3
XFILLER_10_274 VGND VGND VPWR VPWR sky130_fd_sc_hd__fill_2
XFILLER_109_685 VGND VGND VPWR VPWR sky130_fd_sc_hd__decap_3
XFILLER_40_72 VGND VGND VPWR VPWR sky130_fd_sc_hd__decap_3
XFILLER_108_195 VGND VGND VPWR VPWR sky130_fd_sc_hd__fill_1
XFILLER_6_289 VGND VGND VPWR VPWR sky130_fd_sc_hd__decap_3
XFILLER_97_517 VGND VGND VPWR VPWR sky130_fd_sc_hd__decap_3
XFILLER_2_451 VGND VGND VPWR VPWR sky130_fd_sc_hd__decap_3
XFILLER_111_349 VGND VGND VPWR VPWR sky130_fd_sc_hd__decap_3
XFILLER_49_70 VGND VGND VPWR VPWR sky130_fd_sc_hd__fill_1
XFILLER_1_11 VGND VGND VPWR VPWR sky130_fd_sc_hd__decap_3
XTAP_TAPCELL_ROW_88_1304 VGND VPWR sky130_fd_sc_hd__tapvpwrvgnd_1
XFILLER_1_44 VGND VGND VPWR VPWR sky130_fd_sc_hd__decap_3
XFILLER_38_639 VGND VGND VPWR VPWR sky130_fd_sc_hd__fill_2
XFILLER_65_425 VGND VGND VPWR VPWR sky130_fd_sc_hd__decap_3
XFILLER_65_447 VGND VGND VPWR VPWR sky130_fd_sc_hd__fill_1
XFILLER_18_330 VGND VGND VPWR VPWR sky130_fd_sc_hd__decap_3
XFILLER_1_66 VGND VGND VPWR VPWR sky130_fd_sc_hd__decap_3
XFILLER_1_99 VGND VGND VPWR VPWR sky130_fd_sc_hd__decap_3
XFILLER_65_469 VGND VGND VPWR VPWR sky130_fd_sc_hd__fill_1
XFILLER_18_363 VGND VGND VPWR VPWR sky130_fd_sc_hd__fill_1
XFILLER_33_300 VGND VGND VPWR VPWR sky130_fd_sc_hd__decap_3
XFILLER_46_672 VGND VGND VPWR VPWR sky130_fd_sc_hd__decap_3
XFILLER_61_620 VGND VGND VPWR VPWR sky130_fd_sc_hd__decap_3
XFILLER_65_80 VGND VGND VPWR VPWR sky130_fd_sc_hd__decap_3
XFILLER_33_322 VGND VGND VPWR VPWR sky130_fd_sc_hd__fill_2
XFILLER_61_653 VGND VGND VPWR VPWR sky130_fd_sc_hd__decap_3
X_4830_ _4646_/Y _4827_/A _4829_/Y VGND VGND VPWR VPWR _4830_/X sky130_fd_sc_hd__o21a_2
XFILLER_81_90 VGND VGND VPWR VPWR sky130_fd_sc_hd__decap_3
X_4761_ _4762_/B _4761_/B _4761_/C VGND VGND VPWR VPWR _4761_/Y sky130_fd_sc_hd__nand3_2
X_6500_ _6568_/A VGND VGND VPWR VPWR _6500_/Y sky130_fd_sc_hd__inv_2
X_4692_ _7006_/Q _4749_/B VGND VGND VPWR VPWR _4750_/B sky130_fd_sc_hd__and2_2
X_3712_ _3746_/B VGND VGND VPWR VPWR _3741_/B sky130_fd_sc_hd__inv_2
XTAP_TAPCELL_ROW_99_1444 VGND VPWR sky130_fd_sc_hd__tapvpwrvgnd_1
X_6431_ _6637_/A VGND VGND VPWR VPWR _6431_/Y sky130_fd_sc_hd__inv_2
XFILLER_115_600 VGND VGND VPWR VPWR sky130_fd_sc_hd__decap_3
X_6362_ _6385_/A VGND VGND VPWR VPWR _6362_/Y sky130_fd_sc_hd__inv_2
XFILLER_115_644 VGND VGND VPWR VPWR sky130_fd_sc_hd__decap_3
X_3574_ _7348_/Q _4338_/B1 _3573_/X _3556_/A VGND VGND VPWR VPWR _3574_/X sky130_fd_sc_hd__a211o_2
XFILLER_114_121 VGND VGND VPWR VPWR sky130_fd_sc_hd__decap_3
X_6293_ _6535_/A VGND VGND VPWR VPWR _6293_/Y sky130_fd_sc_hd__inv_2
XFILLER_114_165 VGND VGND VPWR VPWR sky130_fd_sc_hd__decap_3
XFILLER_88_539 VGND VGND VPWR VPWR sky130_fd_sc_hd__fill_1
XFILLER_102_338 VGND VGND VPWR VPWR sky130_fd_sc_hd__decap_3
XFILLER_29_18 VGND VGND VPWR VPWR sky130_fd_sc_hd__decap_3
X_5175_ _5175_/A _5194_/B VGND VGND VPWR VPWR _7240_/D sky130_fd_sc_hd__and2_2
XFILLER_29_617 VGND VGND VPWR VPWR sky130_fd_sc_hd__fill_2
XFILLER_96_561 VGND VGND VPWR VPWR sky130_fd_sc_hd__decap_3
X_4126_ _4126_/A _4125_/X VGND VGND VPWR VPWR _4890_/B sky130_fd_sc_hd__or2b_2
XFILLER_28_138 VGND VGND VPWR VPWR sky130_fd_sc_hd__fill_2
XFILLER_83_200 VGND VGND VPWR VPWR sky130_fd_sc_hd__fill_1
XFILLER_83_222 VGND VGND VPWR VPWR sky130_fd_sc_hd__fill_2
XFILLER_56_469 VGND VGND VPWR VPWR sky130_fd_sc_hd__decap_3
X_4057_ _7308_/Q _4478_/S _4437_/B1 _7372_/Q _4429_/C1 VGND VGND VPWR VPWR _4057_/X
+ sky130_fd_sc_hd__a221o_2
XFILLER_43_119 VGND VGND VPWR VPWR sky130_fd_sc_hd__fill_1
XFILLER_45_39 VGND VGND VPWR VPWR sky130_fd_sc_hd__decap_3
XFILLER_71_417 VGND VGND VPWR VPWR sky130_fd_sc_hd__fill_1
XFILLER_71_439 VGND VGND VPWR VPWR sky130_fd_sc_hd__decap_3
XFILLER_83_299 VGND VGND VPWR VPWR sky130_fd_sc_hd__decap_3
XTAP_TAPCELL_ROW_108_1551 VGND VPWR sky130_fd_sc_hd__tapvpwrvgnd_1
XFILLER_52_631 VGND VGND VPWR VPWR sky130_fd_sc_hd__decap_3
XFILLER_101_67 VGND VGND VPWR VPWR sky130_fd_sc_hd__fill_2
XFILLER_51_141 VGND VGND VPWR VPWR sky130_fd_sc_hd__decap_3
XFILLER_52_675 VGND VGND VPWR VPWR sky130_fd_sc_hd__decap_3
XFILLER_101_89 VGND VGND VPWR VPWR sky130_fd_sc_hd__fill_1
XFILLER_51_196 VGND VGND VPWR VPWR sky130_fd_sc_hd__decap_3
XFILLER_61_49 VGND VGND VPWR VPWR sky130_fd_sc_hd__decap_3
X_4959_ _6993_/Q _4958_/Y _6994_/Q VGND VGND VPWR VPWR _4960_/C sky130_fd_sc_hd__a21oi_2
XTAP_TAPCELL_ROW_22_512 VGND VPWR sky130_fd_sc_hd__tapvpwrvgnd_1
XFILLER_20_550 VGND VGND VPWR VPWR sky130_fd_sc_hd__decap_3
XTAP_TAPCELL_ROW_50_854 VGND VPWR sky130_fd_sc_hd__tapvpwrvgnd_1
X_6629_ _6660_/A VGND VGND VPWR VPWR _6629_/Y sky130_fd_sc_hd__inv_2
XFILLER_105_110 VGND VGND VPWR VPWR sky130_fd_sc_hd__fill_2
XFILLER_106_666 VGND VGND VPWR VPWR sky130_fd_sc_hd__decap_3
XFILLER_10_53 VGND VGND VPWR VPWR sky130_fd_sc_hd__decap_3
XFILLER_3_237 VGND VGND VPWR VPWR sky130_fd_sc_hd__fill_1
XTAP_TAPCELL_ROW_72_1116 VGND VPWR sky130_fd_sc_hd__tapvpwrvgnd_1
XFILLER_105_165 VGND VGND VPWR VPWR sky130_fd_sc_hd__decap_3
XFILLER_79_517 VGND VGND VPWR VPWR sky130_fd_sc_hd__decap_3
XFILLER_79_528 VGND VGND VPWR VPWR sky130_fd_sc_hd__decap_3
XFILLER_86_24 VGND VGND VPWR VPWR sky130_fd_sc_hd__decap_3
XFILLER_86_46 VGND VGND VPWR VPWR sky130_fd_sc_hd__decap_3
XFILLER_101_360 VGND VGND VPWR VPWR sky130_fd_sc_hd__decap_3
XFILLER_19_105 VGND VGND VPWR VPWR sky130_fd_sc_hd__decap_3
XFILLER_86_79 VGND VGND VPWR VPWR sky130_fd_sc_hd__decap_3
XFILLER_87_561 VGND VGND VPWR VPWR sky130_fd_sc_hd__decap_3
XFILLER_101_393 VGND VGND VPWR VPWR sky130_fd_sc_hd__decap_3
XFILLER_19_73 VGND VGND VPWR VPWR sky130_fd_sc_hd__decap_3
XFILLER_74_200 VGND VGND VPWR VPWR sky130_fd_sc_hd__decap_3
XTAP_TAPCELL_ROW_58_943 VGND VPWR sky130_fd_sc_hd__tapvpwrvgnd_1
XFILLER_62_406 VGND VGND VPWR VPWR sky130_fd_sc_hd__fill_2
XFILLER_15_311 VGND VGND VPWR VPWR sky130_fd_sc_hd__decap_3
XFILLER_43_620 VGND VGND VPWR VPWR sky130_fd_sc_hd__decap_3
XFILLER_62_417 VGND VGND VPWR VPWR sky130_fd_sc_hd__decap_3
XFILLER_62_439 VGND VGND VPWR VPWR sky130_fd_sc_hd__decap_3
XFILLER_74_277 VGND VGND VPWR VPWR sky130_fd_sc_hd__decap_3
XTAP_TAPCELL_ROW_2_281 VGND VPWR sky130_fd_sc_hd__tapvpwrvgnd_1
XTAP_TAPCELL_ROW_2_270 VGND VPWR sky130_fd_sc_hd__tapvpwrvgnd_1
XFILLER_27_193 VGND VGND VPWR VPWR sky130_fd_sc_hd__fill_1
XFILLER_43_653 VGND VGND VPWR VPWR sky130_fd_sc_hd__decap_3
XTAP_TAPCELL_ROW_83_1245 VGND VPWR sky130_fd_sc_hd__tapvpwrvgnd_1
XFILLER_35_72 VGND VGND VPWR VPWR sky130_fd_sc_hd__decap_3
XFILLER_42_141 VGND VGND VPWR VPWR sky130_fd_sc_hd__decap_3
XFILLER_42_185 VGND VGND VPWR VPWR sky130_fd_sc_hd__decap_3
XFILLER_70_483 VGND VGND VPWR VPWR sky130_fd_sc_hd__decap_3
XFILLER_11_561 VGND VGND VPWR VPWR sky130_fd_sc_hd__fill_1
XFILLER_51_82 VGND VGND VPWR VPWR sky130_fd_sc_hd__decap_3
XFILLER_7_521 VGND VGND VPWR VPWR sky130_fd_sc_hd__decap_3
XFILLER_7_532 VGND VGND VPWR VPWR sky130_fd_sc_hd__decap_3
XTAP_TAPCELL_ROW_94_1374 VGND VPWR sky130_fd_sc_hd__tapvpwrvgnd_1
XFILLER_111_102 VGND VGND VPWR VPWR sky130_fd_sc_hd__decap_3
XFILLER_112_625 VGND VGND VPWR VPWR sky130_fd_sc_hd__decap_3
XTAP_TAPCELL_ROW_94_1385 VGND VPWR sky130_fd_sc_hd__tapvpwrvgnd_1
XFILLER_111_113 VGND VGND VPWR VPWR sky130_fd_sc_hd__decap_3
XFILLER_112_669 VGND VGND VPWR VPWR sky130_fd_sc_hd__decap_3
XFILLER_2_292 VGND VGND VPWR VPWR sky130_fd_sc_hd__decap_3
XFILLER_111_146 VGND VGND VPWR VPWR sky130_fd_sc_hd__decap_3
XFILLER_18_3 VGND VGND VPWR VPWR sky130_fd_sc_hd__decap_3
XFILLER_65_211 VGND VGND VPWR VPWR sky130_fd_sc_hd__decap_3
XFILLER_93_531 VGND VGND VPWR VPWR sky130_fd_sc_hd__decap_3
X_6980_ _7330_/CLK _6980_/D _6260_/Y VGND VGND VPWR VPWR _6980_/Q sky130_fd_sc_hd__dfrtp_2
XFILLER_18_160 VGND VGND VPWR VPWR sky130_fd_sc_hd__decap_3
XFILLER_25_108 VGND VGND VPWR VPWR sky130_fd_sc_hd__decap_3
XFILLER_53_417 VGND VGND VPWR VPWR sky130_fd_sc_hd__decap_3
XFILLER_65_277 VGND VGND VPWR VPWR sky130_fd_sc_hd__decap_3
XFILLER_65_299 VGND VGND VPWR VPWR sky130_fd_sc_hd__decap_3
XFILLER_80_203 VGND VGND VPWR VPWR sky130_fd_sc_hd__fill_2
XFILLER_93_586 VGND VGND VPWR VPWR sky130_fd_sc_hd__decap_3
XFILLER_34_620 VGND VGND VPWR VPWR sky130_fd_sc_hd__fill_2
XFILLER_33_141 VGND VGND VPWR VPWR sky130_fd_sc_hd__decap_3
XFILLER_34_686 VGND VGND VPWR VPWR sky130_fd_sc_hd__decap_3
XFILLER_21_325 VGND VGND VPWR VPWR sky130_fd_sc_hd__decap_3
XFILLER_33_196 VGND VGND VPWR VPWR sky130_fd_sc_hd__decap_3
X_4813_ _4813_/A _4813_/B VGND VGND VPWR VPWR _4813_/Y sky130_fd_sc_hd__nand2_2
XFILLER_21_347 VGND VGND VPWR VPWR sky130_fd_sc_hd__decap_3
X_4744_ _4938_/A _4744_/B VGND VGND VPWR VPWR _4744_/Y sky130_fd_sc_hd__nor2_2
XTAP_TAPCELL_ROW_103_1492 VGND VPWR sky130_fd_sc_hd__tapvpwrvgnd_1
X_4675_ _3469_/A _3469_/B _3564_/X _3449_/A _6984_/Q VGND VGND VPWR VPWR _5067_/B
+ sky130_fd_sc_hd__o2111a_2
X_7394_ _7401_/CLK _7394_/D _6674_/Y VGND VGND VPWR VPWR _7394_/Q sky130_fd_sc_hd__dfrtp_2
X_6414_ _6606_/A VGND VGND VPWR VPWR _6414_/Y sky130_fd_sc_hd__inv_2
X_3626_ _3616_/Y _3617_/X _3625_/X VGND VGND VPWR VPWR _3733_/C sky130_fd_sc_hd__a21oi_4
XFILLER_115_452 VGND VGND VPWR VPWR sky130_fd_sc_hd__fill_1
X_6345_ _6540_/A VGND VGND VPWR VPWR _6345_/Y sky130_fd_sc_hd__inv_2
X_3557_ _7221_/Q _4340_/A2 wire566/X _7125_/Q _3556_/X VGND VGND VPWR VPWR _3557_/X
+ sky130_fd_sc_hd__a221o_2
XFILLER_103_614 VGND VGND VPWR VPWR sky130_fd_sc_hd__fill_2
XFILLER_88_303 VGND VGND VPWR VPWR sky130_fd_sc_hd__decap_3
X_6276_ _6652_/A VGND VGND VPWR VPWR _6276_/Y sky130_fd_sc_hd__inv_2
XFILLER_102_124 VGND VGND VPWR VPWR sky130_fd_sc_hd__decap_3
XFILLER_103_669 VGND VGND VPWR VPWR sky130_fd_sc_hd__decap_3
XFILLER_88_347 VGND VGND VPWR VPWR sky130_fd_sc_hd__decap_3
X_5227_ _5227_/A1 _5194_/B _5655_/B VGND VGND VPWR VPWR _7215_/D sky130_fd_sc_hd__a21o_2
X_3488_ _7279_/Q _4532_/S VGND VGND VPWR VPWR _3488_/X sky130_fd_sc_hd__and2_2
XFILLER_111_691 VGND VGND VPWR VPWR sky130_fd_sc_hd__fill_1
XFILLER_29_414 VGND VGND VPWR VPWR sky130_fd_sc_hd__decap_3
XFILLER_29_436 VGND VGND VPWR VPWR sky130_fd_sc_hd__decap_3
XFILLER_17_609 VGND VGND VPWR VPWR sky130_fd_sc_hd__decap_3
XFILLER_56_244 VGND VGND VPWR VPWR sky130_fd_sc_hd__decap_3
XFILLER_84_564 VGND VGND VPWR VPWR sky130_fd_sc_hd__decap_3
X_5089_ _3618_/C _4315_/A _5086_/A _5101_/A _5088_/X VGND VGND VPWR VPWR _5089_/Y
+ sky130_fd_sc_hd__o221ai_2
X_4109_ _4376_/A _4141_/A _4141_/B _4142_/C VGND VGND VPWR VPWR _4109_/X sky130_fd_sc_hd__o31a_2
XFILLER_112_11 VGND VGND VPWR VPWR sky130_fd_sc_hd__decap_3
XFILLER_56_277 VGND VGND VPWR VPWR sky130_fd_sc_hd__decap_3
XFILLER_71_214 VGND VGND VPWR VPWR sky130_fd_sc_hd__decap_3
XTAP_TAPCELL_ROW_55_913 VGND VPWR sky130_fd_sc_hd__tapvpwrvgnd_1
XFILLER_112_44 VGND VGND VPWR VPWR sky130_fd_sc_hd__decap_3
XFILLER_112_77 VGND VGND VPWR VPWR sky130_fd_sc_hd__decap_3
XFILLER_25_620 VGND VGND VPWR VPWR sky130_fd_sc_hd__decap_3
XFILLER_71_258 VGND VGND VPWR VPWR sky130_fd_sc_hd__decap_3
XFILLER_112_88 VGND VGND VPWR VPWR sky130_fd_sc_hd__decap_3
XFILLER_24_141 VGND VGND VPWR VPWR sky130_fd_sc_hd__decap_3
XFILLER_72_26 VGND VGND VPWR VPWR sky130_fd_sc_hd__fill_2
XFILLER_72_48 VGND VGND VPWR VPWR sky130_fd_sc_hd__decap_3
XFILLER_12_336 VGND VGND VPWR VPWR sky130_fd_sc_hd__decap_3
XFILLER_24_185 VGND VGND VPWR VPWR sky130_fd_sc_hd__decap_3
XTAP_TAPCELL_ROW_35_670 VGND VPWR sky130_fd_sc_hd__tapvpwrvgnd_1
XFILLER_40_656 VGND VGND VPWR VPWR sky130_fd_sc_hd__decap_3
XFILLER_40_689 VGND VGND VPWR VPWR sky130_fd_sc_hd__decap_3
XFILLER_20_391 VGND VGND VPWR VPWR sky130_fd_sc_hd__decap_3
XFILLER_21_63 VGND VGND VPWR VPWR sky130_fd_sc_hd__fill_1
XFILLER_4_524 VGND VGND VPWR VPWR sky130_fd_sc_hd__decap_3
XFILLER_21_96 VGND VGND VPWR VPWR sky130_fd_sc_hd__decap_3
XFILLER_4_557 VGND VGND VPWR VPWR sky130_fd_sc_hd__fill_2
XFILLER_97_12 VGND VGND VPWR VPWR sky130_fd_sc_hd__decap_3
XFILLER_106_474 VGND VGND VPWR VPWR sky130_fd_sc_hd__fill_2
XFILLER_106_485 VGND VGND VPWR VPWR sky130_fd_sc_hd__decap_3
XFILLER_79_325 VGND VGND VPWR VPWR sky130_fd_sc_hd__decap_3
XFILLER_97_67 VGND VGND VPWR VPWR sky130_fd_sc_hd__decap_3
XTAP_TAPCELL_ROW_7_340 VGND VPWR sky130_fd_sc_hd__tapvpwrvgnd_1
XFILLER_97_89 VGND VGND VPWR VPWR sky130_fd_sc_hd__decap_3
XFILLER_47_200 VGND VGND VPWR VPWR sky130_fd_sc_hd__decap_3
XFILLER_47_222 VGND VGND VPWR VPWR sky130_fd_sc_hd__fill_2
XFILLER_75_520 VGND VGND VPWR VPWR sky130_fd_sc_hd__decap_3
XFILLER_87_380 VGND VGND VPWR VPWR sky130_fd_sc_hd__decap_3
XFILLER_87_391 VGND VGND VPWR VPWR sky130_fd_sc_hd__fill_1
XFILLER_101_190 VGND VGND VPWR VPWR sky130_fd_sc_hd__decap_3
XFILLER_47_233 VGND VGND VPWR VPWR sky130_fd_sc_hd__decap_3
XFILLER_75_553 VGND VGND VPWR VPWR sky130_fd_sc_hd__decap_3
XFILLER_35_428 VGND VGND VPWR VPWR sky130_fd_sc_hd__fill_2
XFILLER_62_203 VGND VGND VPWR VPWR sky130_fd_sc_hd__decap_3
XFILLER_90_523 VGND VGND VPWR VPWR sky130_fd_sc_hd__fill_1
XFILLER_90_545 VGND VGND VPWR VPWR sky130_fd_sc_hd__decap_3
XFILLER_43_461 VGND VGND VPWR VPWR sky130_fd_sc_hd__fill_2
XFILLER_90_589 VGND VGND VPWR VPWR sky130_fd_sc_hd__decap_3
XFILLER_15_196 VGND VGND VPWR VPWR sky130_fd_sc_hd__decap_3
XFILLER_30_100 VGND VGND VPWR VPWR sky130_fd_sc_hd__decap_3
XFILLER_70_280 VGND VGND VPWR VPWR sky130_fd_sc_hd__decap_3
XFILLER_87_6 VGND VGND VPWR VPWR sky130_fd_sc_hd__decap_3
XFILLER_30_188 VGND VGND VPWR VPWR sky130_fd_sc_hd__decap_3
XFILLER_7_21 VGND VGND VPWR VPWR sky130_fd_sc_hd__decap_3
XFILLER_7_54 VGND VGND VPWR VPWR sky130_fd_sc_hd__fill_2
XTAP_TAPCELL_ROW_96_1403 VGND VPWR sky130_fd_sc_hd__tapvpwrvgnd_1
XFILLER_7_362 VGND VGND VPWR VPWR sky130_fd_sc_hd__decap_3
XFILLER_7_87 VGND VGND VPWR VPWR sky130_fd_sc_hd__decap_3
X_4460_ _4460_/A _4460_/B VGND VGND VPWR VPWR _4460_/Y sky130_fd_sc_hd__nand2_2
X_4391_ _7401_/Q _4429_/B1 _4436_/B1 _7177_/Q _4390_/X VGND VGND VPWR VPWR _4391_/X
+ sky130_fd_sc_hd__a221o_2
X_3342_ _6983_/Q _6982_/Q VGND VGND VPWR VPWR _5118_/D sky130_fd_sc_hd__nand2b_4
XFILLER_97_111 VGND VGND VPWR VPWR sky130_fd_sc_hd__fill_1
XFILLER_98_645 VGND VGND VPWR VPWR sky130_fd_sc_hd__fill_1
XFILLER_97_155 VGND VGND VPWR VPWR sky130_fd_sc_hd__decap_3
XFILLER_98_678 VGND VGND VPWR VPWR sky130_fd_sc_hd__decap_3
XFILLER_100_639 VGND VGND VPWR VPWR sky130_fd_sc_hd__decap_3
XFILLER_38_200 VGND VGND VPWR VPWR sky130_fd_sc_hd__decap_3
XFILLER_66_520 VGND VGND VPWR VPWR sky130_fd_sc_hd__decap_3
XFILLER_97_177 VGND VGND VPWR VPWR sky130_fd_sc_hd__decap_3
Xhold1007 _7206_/Q VGND VGND VPWR VPWR _5247_/A0 sky130_fd_sc_hd__dlygate4sd3_1
Xhold1018 _7272_/Q VGND VGND VPWR VPWR _4823_/A0 sky130_fd_sc_hd__dlygate4sd3_1
Xhold1029 _7234_/Q VGND VGND VPWR VPWR _5188_/A sky130_fd_sc_hd__dlygate4sd3_1
X_5012_ _5012_/A0 _5011_/X _5080_/S VGND VGND VPWR VPWR _7261_/D sky130_fd_sc_hd__mux2_2
XFILLER_66_542 VGND VGND VPWR VPWR sky130_fd_sc_hd__decap_3
XFILLER_53_214 VGND VGND VPWR VPWR sky130_fd_sc_hd__fill_2
XFILLER_66_586 VGND VGND VPWR VPWR sky130_fd_sc_hd__fill_2
XFILLER_81_523 VGND VGND VPWR VPWR sky130_fd_sc_hd__decap_3
XFILLER_93_361 VGND VGND VPWR VPWR sky130_fd_sc_hd__decap_3
XFILLER_19_491 VGND VGND VPWR VPWR sky130_fd_sc_hd__decap_3
XFILLER_26_439 VGND VGND VPWR VPWR sky130_fd_sc_hd__fill_2
XFILLER_53_225 VGND VGND VPWR VPWR sky130_fd_sc_hd__decap_3
XFILLER_81_534 VGND VGND VPWR VPWR sky130_fd_sc_hd__decap_3
X_6963_ _6972_/CLK _6963_/D VGND VGND VPWR VPWR _6963_/Q sky130_fd_sc_hd__dfxtp_2
XTAP_TAPCELL_ROW_105_1510 VGND VPWR sky130_fd_sc_hd__tapvpwrvgnd_1
XFILLER_34_461 VGND VGND VPWR VPWR sky130_fd_sc_hd__decap_3
XFILLER_53_258 VGND VGND VPWR VPWR sky130_fd_sc_hd__decap_3
X_6894_ _6959_/CLK _6894_/D VGND VGND VPWR VPWR _6894_/Q sky130_fd_sc_hd__dfxtp_2
XFILLER_21_122 VGND VGND VPWR VPWR sky130_fd_sc_hd__decap_3
XFILLER_22_645 VGND VGND VPWR VPWR sky130_fd_sc_hd__fill_2
XFILLER_42_18 VGND VGND VPWR VPWR sky130_fd_sc_hd__decap_3
XFILLER_42_29 VGND VGND VPWR VPWR sky130_fd_sc_hd__fill_2
XTAP_TAPCELL_ROW_32_640 VGND VPWR sky130_fd_sc_hd__tapvpwrvgnd_1
XFILLER_21_155 VGND VGND VPWR VPWR sky130_fd_sc_hd__decap_3
XTAP_TAPCELL_ROW_60_971 VGND VPWR sky130_fd_sc_hd__tapvpwrvgnd_1
XFILLER_21_199 VGND VGND VPWR VPWR sky130_fd_sc_hd__decap_3
X_4727_ _7007_/Q _4750_/B _4777_/A VGND VGND VPWR VPWR _4728_/B sky130_fd_sc_hd__o21a_2
XFILLER_107_205 VGND VGND VPWR VPWR sky130_fd_sc_hd__decap_3
X_4658_ _4658_/A _4658_/B VGND VGND VPWR VPWR _4658_/Y sky130_fd_sc_hd__nand2_2
Xhold830 _6930_/Q VGND VGND VPWR VPWR _6930_/D sky130_fd_sc_hd__dlygate4sd3_1
X_3609_ _5071_/A _5072_/A VGND VGND VPWR VPWR _3610_/B sky130_fd_sc_hd__nand2_2
XTAP_TAPCELL_ROW_116_1661 VGND VPWR sky130_fd_sc_hd__tapvpwrvgnd_1
XTAP_TAPCELL_ROW_116_1650 VGND VPWR sky130_fd_sc_hd__tapvpwrvgnd_1
XFILLER_107_11 VGND VGND VPWR VPWR sky130_fd_sc_hd__decap_3
XFILLER_89_601 VGND VGND VPWR VPWR sky130_fd_sc_hd__decap_3
X_7377_ _7387_/CLK _7377_/D _6657_/Y VGND VGND VPWR VPWR _7377_/Q sky130_fd_sc_hd__dfrtp_2
Xhold841 _7076_/Q VGND VGND VPWR VPWR _7076_/D sky130_fd_sc_hd__dlygate4sd3_1
Xhold852 _7056_/Q VGND VGND VPWR VPWR _7056_/D sky130_fd_sc_hd__dlygate4sd3_1
Xhold863 _7116_/Q VGND VGND VPWR VPWR _7116_/D sky130_fd_sc_hd__dlygate4sd3_1
Xmax_cap571 _6395_/A VGND VGND VPWR VPWR _6523_/A sky130_fd_sc_hd__buf_2
X_4589_ _7286_/Q _4595_/B VGND VGND VPWR VPWR _7286_/D sky130_fd_sc_hd__and2_2
XFILLER_107_44 VGND VGND VPWR VPWR sky130_fd_sc_hd__decap_3
XFILLER_107_66 VGND VGND VPWR VPWR sky130_fd_sc_hd__decap_3
XFILLER_115_293 VGND VGND VPWR VPWR sky130_fd_sc_hd__decap_3
Xhold874 _7091_/Q VGND VGND VPWR VPWR _7091_/D sky130_fd_sc_hd__dlygate4sd3_1
Xhold885 _7060_/Q VGND VGND VPWR VPWR _7060_/D sky130_fd_sc_hd__dlygate4sd3_1
Xhold896 _7117_/Q VGND VGND VPWR VPWR _7117_/D sky130_fd_sc_hd__dlygate4sd3_1
X_6328_ _6675_/A VGND VGND VPWR VPWR _6328_/Y sky130_fd_sc_hd__inv_2
XFILLER_103_466 VGND VGND VPWR VPWR sky130_fd_sc_hd__decap_3
XFILLER_67_15 VGND VGND VPWR VPWR sky130_fd_sc_hd__decap_3
XFILLER_67_48 VGND VGND VPWR VPWR sky130_fd_sc_hd__decap_3
XFILLER_88_144 VGND VGND VPWR VPWR sky130_fd_sc_hd__decap_3
X_6259_ _6385_/A VGND VGND VPWR VPWR _6259_/Y sky130_fd_sc_hd__inv_2
XFILLER_29_211 VGND VGND VPWR VPWR sky130_fd_sc_hd__fill_1
XFILLER_88_177 VGND VGND VPWR VPWR sky130_fd_sc_hd__decap_3
XFILLER_29_233 VGND VGND VPWR VPWR sky130_fd_sc_hd__decap_3
XFILLER_57_542 VGND VGND VPWR VPWR sky130_fd_sc_hd__fill_1
XFILLER_69_391 VGND VGND VPWR VPWR sky130_fd_sc_hd__fill_1
XFILLER_57_586 VGND VGND VPWR VPWR sky130_fd_sc_hd__decap_3
XFILLER_72_501 VGND VGND VPWR VPWR sky130_fd_sc_hd__decap_3
XFILLER_29_299 VGND VGND VPWR VPWR sky130_fd_sc_hd__decap_3
XFILLER_83_36 VGND VGND VPWR VPWR sky130_fd_sc_hd__decap_3
XFILLER_83_69 VGND VGND VPWR VPWR sky130_fd_sc_hd__decap_3
XFILLER_16_41 VGND VGND VPWR VPWR sky130_fd_sc_hd__decap_3
XTAP_TAPCELL_ROW_67_1059 VGND VPWR sky130_fd_sc_hd__tapvpwrvgnd_1
XFILLER_13_612 VGND VGND VPWR VPWR sky130_fd_sc_hd__decap_3
XFILLER_16_85 VGND VGND VPWR VPWR sky130_fd_sc_hd__decap_3
XFILLER_25_483 VGND VGND VPWR VPWR sky130_fd_sc_hd__decap_3
XTAP_TAPCELL_ROW_80_1215 VGND VPWR sky130_fd_sc_hd__tapvpwrvgnd_1
XPHY_EDGE_ROW_11_Right_11 VGND VGND VPWR VPWR sky130_fd_sc_hd__decap_3
XFILLER_13_656 VGND VGND VPWR VPWR sky130_fd_sc_hd__decap_3
XFILLER_40_475 VGND VGND VPWR VPWR sky130_fd_sc_hd__fill_1
XFILLER_8_126 VGND VGND VPWR VPWR sky130_fd_sc_hd__decap_3
XFILLER_32_62 VGND VGND VPWR VPWR sky130_fd_sc_hd__decap_3
XTAP_TAPCELL_ROW_10_367 VGND VPWR sky130_fd_sc_hd__tapvpwrvgnd_1
XFILLER_113_208 VGND VGND VPWR VPWR sky130_fd_sc_hd__decap_3
XFILLER_4_365 VGND VGND VPWR VPWR sky130_fd_sc_hd__fill_1
XTAP_TAPCELL_ROW_78_1188 VGND VPWR sky130_fd_sc_hd__tapvpwrvgnd_1
XFILLER_79_100 VGND VGND VPWR VPWR sky130_fd_sc_hd__decap_3
XFILLER_79_122 VGND VGND VPWR VPWR sky130_fd_sc_hd__decap_3
XTAP_TAPCELL_ROW_91_1344 VGND VPWR sky130_fd_sc_hd__tapvpwrvgnd_1
XPHY_EDGE_ROW_20_Right_20 VGND VGND VPWR VPWR sky130_fd_sc_hd__decap_3
XFILLER_79_155 VGND VGND VPWR VPWR sky130_fd_sc_hd__decap_3
XFILLER_79_199 VGND VGND VPWR VPWR sky130_fd_sc_hd__fill_2
XFILLER_48_531 VGND VGND VPWR VPWR sky130_fd_sc_hd__fill_1
XFILLER_82_309 VGND VGND VPWR VPWR sky130_fd_sc_hd__decap_3
XFILLER_94_147 VGND VGND VPWR VPWR sky130_fd_sc_hd__fill_1
XFILLER_95_659 VGND VGND VPWR VPWR sky130_fd_sc_hd__decap_3
XFILLER_57_81 VGND VGND VPWR VPWR sky130_fd_sc_hd__decap_3
XFILLER_63_501 VGND VGND VPWR VPWR sky130_fd_sc_hd__decap_3
XFILLER_75_361 VGND VGND VPWR VPWR sky130_fd_sc_hd__decap_3
XFILLER_35_214 VGND VGND VPWR VPWR sky130_fd_sc_hd__decap_3
XFILLER_35_225 VGND VGND VPWR VPWR sky130_fd_sc_hd__decap_3
XFILLER_35_247 VGND VGND VPWR VPWR sky130_fd_sc_hd__decap_3
XFILLER_50_206 VGND VGND VPWR VPWR sky130_fd_sc_hd__decap_3
XFILLER_90_342 VGND VGND VPWR VPWR sky130_fd_sc_hd__decap_3
X_3960_ _7360_/Q _4503_/A0 _4471_/S VGND VGND VPWR VPWR _7360_/D sky130_fd_sc_hd__mux2_2
XTAP_TAPCELL_ROW_18_467 VGND VPWR sky130_fd_sc_hd__tapvpwrvgnd_1
XTAP_TAPCELL_ROW_46_798 VGND VPWR sky130_fd_sc_hd__tapvpwrvgnd_1
X_3891_ _6951_/Q _3891_/A2 _3891_/B1 _6957_/Q _3890_/X VGND VGND VPWR VPWR _3891_/X
+ sky130_fd_sc_hd__a221o_2
X_5630_ _5630_/A _5634_/B VGND VGND VPWR VPWR _7013_/D sky130_fd_sc_hd__and2_2
XTAP_TAPCELL_ROW_100_1451 VGND VPWR sky130_fd_sc_hd__tapvpwrvgnd_1
X_5561_ hold985/X _4777_/A _4695_/X VGND VGND VPWR VPWR _7054_/D sky130_fd_sc_hd__o21a_2
XFILLER_8_682 VGND VGND VPWR VPWR sky130_fd_sc_hd__fill_2
X_7300_ _7365_/CLK _7300_/D _6580_/Y VGND VGND VPWR VPWR _7300_/Q sky130_fd_sc_hd__dfrtp_2
XFILLER_7_181 VGND VGND VPWR VPWR sky130_fd_sc_hd__fill_1
X_7231_ _7264_/CLK _7231_/D _6511_/Y VGND VGND VPWR VPWR _7231_/Q sky130_fd_sc_hd__dfrtp_2
X_4443_ _4778_/A _4778_/B _4647_/C _4787_/A _4779_/A VGND VGND VPWR VPWR _4761_/B
+ sky130_fd_sc_hd__a2111o_2
X_7162_ _7279_/CLK _7162_/D _6442_/Y VGND VGND VPWR VPWR _7162_/Q sky130_fd_sc_hd__dfrtp_2
X_4374_ _4371_/Y _4224_/C _4373_/Y VGND VGND VPWR VPWR _4374_/X sky130_fd_sc_hd__o21a_2
XFILLER_112_230 VGND VGND VPWR VPWR sky130_fd_sc_hd__decap_3
X_7093_ clkload7/A _7093_/D _6373_/Y VGND VGND VPWR VPWR _7093_/Q sky130_fd_sc_hd__dfrtp_2
X_3325_ _3323_/X _3324_/X _6983_/Q VGND VGND VPWR VPWR _3326_/B sky130_fd_sc_hd__a21oi_2
XFILLER_112_285 VGND VGND VPWR VPWR sky130_fd_sc_hd__decap_3
XFILLER_85_125 VGND VGND VPWR VPWR sky130_fd_sc_hd__decap_3
XFILLER_86_648 VGND VGND VPWR VPWR sky130_fd_sc_hd__decap_3
XTAP_TAPCELL_ROW_111_1580 VGND VPWR sky130_fd_sc_hd__tapvpwrvgnd_1
XFILLER_98_497 VGND VGND VPWR VPWR sky130_fd_sc_hd__decap_3
XFILLER_100_436 VGND VGND VPWR VPWR sky130_fd_sc_hd__decap_3
XFILLER_100_458 VGND VGND VPWR VPWR sky130_fd_sc_hd__decap_3
XFILLER_37_18 VGND VGND VPWR VPWR sky130_fd_sc_hd__decap_3
XFILLER_85_158 VGND VGND VPWR VPWR sky130_fd_sc_hd__decap_3
XFILLER_86_659 VGND VGND VPWR VPWR sky130_fd_sc_hd__decap_3
XFILLER_26_203 VGND VGND VPWR VPWR sky130_fd_sc_hd__decap_3
XFILLER_66_350 VGND VGND VPWR VPWR sky130_fd_sc_hd__decap_3
XFILLER_66_372 VGND VGND VPWR VPWR sky130_fd_sc_hd__decap_3
XFILLER_94_681 VGND VGND VPWR VPWR sky130_fd_sc_hd__decap_3
XFILLER_26_236 VGND VGND VPWR VPWR sky130_fd_sc_hd__decap_3
XFILLER_39_597 VGND VGND VPWR VPWR sky130_fd_sc_hd__decap_3
XFILLER_54_589 VGND VGND VPWR VPWR sky130_fd_sc_hd__decap_3
XFILLER_81_364 VGND VGND VPWR VPWR sky130_fd_sc_hd__decap_3
X_6946_ _6964_/CLK _6946_/D VGND VGND VPWR VPWR _6946_/Q sky130_fd_sc_hd__dfxtp_2
XFILLER_41_228 VGND VGND VPWR VPWR sky130_fd_sc_hd__decap_3
XFILLER_34_280 VGND VGND VPWR VPWR sky130_fd_sc_hd__decap_3
X_6877_ _6975_/CLK _6877_/D VGND VGND VPWR VPWR _6877_/Q sky130_fd_sc_hd__dfxtp_2
XFILLER_22_475 VGND VGND VPWR VPWR sky130_fd_sc_hd__fill_1
XFILLER_108_536 VGND VGND VPWR VPWR sky130_fd_sc_hd__fill_1
XFILLER_108_569 VGND VGND VPWR VPWR sky130_fd_sc_hd__fill_2
XFILLER_78_14 VGND VGND VPWR VPWR sky130_fd_sc_hd__decap_3
XFILLER_116_580 VGND VGND VPWR VPWR sky130_fd_sc_hd__decap_3
XFILLER_78_47 VGND VGND VPWR VPWR sky130_fd_sc_hd__decap_3
XFILLER_89_420 VGND VGND VPWR VPWR sky130_fd_sc_hd__decap_3
Xhold660 _6798_/Q VGND VGND VPWR VPWR _6798_/D sky130_fd_sc_hd__dlygate4sd3_1
Xhold671 _6794_/Q VGND VGND VPWR VPWR _6794_/D sky130_fd_sc_hd__dlygate4sd3_1
XFILLER_103_241 VGND VGND VPWR VPWR sky130_fd_sc_hd__decap_3
XFILLER_1_346 VGND VGND VPWR VPWR sky130_fd_sc_hd__decap_3
XFILLER_49_306 VGND VGND VPWR VPWR sky130_fd_sc_hd__decap_3
XFILLER_77_615 VGND VGND VPWR VPWR sky130_fd_sc_hd__fill_1
Xhold682 _6802_/Q VGND VGND VPWR VPWR _6802_/D sky130_fd_sc_hd__dlygate4sd3_1
Xhold693 _6952_/Q VGND VGND VPWR VPWR _6952_/D sky130_fd_sc_hd__dlygate4sd3_1
XFILLER_103_263 VGND VGND VPWR VPWR sky130_fd_sc_hd__decap_3
XFILLER_76_147 VGND VGND VPWR VPWR sky130_fd_sc_hd__decap_3
XFILLER_57_361 VGND VGND VPWR VPWR sky130_fd_sc_hd__decap_3
XFILLER_64_309 VGND VGND VPWR VPWR sky130_fd_sc_hd__decap_3
XFILLER_76_169 VGND VGND VPWR VPWR sky130_fd_sc_hd__decap_3
XFILLER_85_670 VGND VGND VPWR VPWR sky130_fd_sc_hd__fill_2
XFILLER_17_225 VGND VGND VPWR VPWR sky130_fd_sc_hd__decap_3
XFILLER_27_40 VGND VGND VPWR VPWR sky130_fd_sc_hd__decap_3
XFILLER_94_79 VGND VGND VPWR VPWR sky130_fd_sc_hd__decap_3
XFILLER_17_258 VGND VGND VPWR VPWR sky130_fd_sc_hd__decap_3
XFILLER_32_206 VGND VGND VPWR VPWR sky130_fd_sc_hd__decap_3
XFILLER_72_397 VGND VGND VPWR VPWR sky130_fd_sc_hd__decap_3
XTAP_TAPCELL_ROW_15_426 VGND VPWR sky130_fd_sc_hd__tapvpwrvgnd_1
XTAP_TAPCELL_ROW_43_768 VGND VPWR sky130_fd_sc_hd__tapvpwrvgnd_1
XTAP_TAPCELL_ROW_15_437 VGND VPWR sky130_fd_sc_hd__tapvpwrvgnd_1
XFILLER_40_250 VGND VGND VPWR VPWR sky130_fd_sc_hd__fill_2
XFILLER_43_72 VGND VGND VPWR VPWR sky130_fd_sc_hd__decap_3
XFILLER_9_424 VGND VGND VPWR VPWR sky130_fd_sc_hd__decap_3
XFILLER_40_272 VGND VGND VPWR VPWR sky130_fd_sc_hd__fill_2
XFILLER_71_9 VGND VGND VPWR VPWR sky130_fd_sc_hd__decap_3
XFILLER_5_652 VGND VGND VPWR VPWR sky130_fd_sc_hd__decap_3
XFILLER_4_184 VGND VGND VPWR VPWR sky130_fd_sc_hd__decap_3
XFILLER_5_685 VGND VGND VPWR VPWR sky130_fd_sc_hd__decap_3
XFILLER_99_239 VGND VGND VPWR VPWR sky130_fd_sc_hd__decap_3
XFILLER_4_44 VGND VGND VPWR VPWR sky130_fd_sc_hd__decap_3
XFILLER_4_77 VGND VGND VPWR VPWR sky130_fd_sc_hd__decap_3
XFILLER_4_88 VGND VGND VPWR VPWR sky130_fd_sc_hd__decap_3
XFILLER_68_637 VGND VGND VPWR VPWR sky130_fd_sc_hd__decap_3
XFILLER_68_648 VGND VGND VPWR VPWR sky130_fd_sc_hd__decap_3
XFILLER_95_401 VGND VGND VPWR VPWR sky130_fd_sc_hd__decap_3
XFILLER_67_147 VGND VGND VPWR VPWR sky130_fd_sc_hd__decap_3
XFILLER_67_158 VGND VGND VPWR VPWR sky130_fd_sc_hd__decap_3
XFILLER_68_91 VGND VGND VPWR VPWR sky130_fd_sc_hd__decap_3
XFILLER_95_434 VGND VGND VPWR VPWR sky130_fd_sc_hd__decap_3
XFILLER_95_467 VGND VGND VPWR VPWR sky130_fd_sc_hd__decap_3
X_4090_ _7302_/Q _4879_/S _4088_/X _4089_/X VGND VGND VPWR VPWR _4090_/X sky130_fd_sc_hd__a211o_2
XFILLER_67_169 VGND VGND VPWR VPWR sky130_fd_sc_hd__fill_2
XFILLER_82_106 VGND VGND VPWR VPWR sky130_fd_sc_hd__decap_3
XFILLER_48_372 VGND VGND VPWR VPWR sky130_fd_sc_hd__decap_3
XFILLER_76_681 VGND VGND VPWR VPWR sky130_fd_sc_hd__decap_3
XFILLER_82_139 VGND VGND VPWR VPWR sky130_fd_sc_hd__fill_1
XFILLER_63_364 VGND VGND VPWR VPWR sky130_fd_sc_hd__decap_3
XFILLER_91_673 VGND VGND VPWR VPWR sky130_fd_sc_hd__decap_3
Xplace331 _4351_/B1 VGND VGND VPWR VPWR _4195_/A2 sky130_fd_sc_hd__buf_2
Xplace320 _4356_/A2 VGND VGND VPWR VPWR _4408_/A2 sky130_fd_sc_hd__buf_2
X_6800_ _6965_/CLK _6800_/D VGND VGND VPWR VPWR _6800_/Q sky130_fd_sc_hd__dfxtp_2
XFILLER_36_589 VGND VGND VPWR VPWR sky130_fd_sc_hd__decap_3
Xplace364 _4419_/C1 VGND VGND VPWR VPWR _4429_/C1 sky130_fd_sc_hd__buf_2
Xplace353 _4879_/S VGND VGND VPWR VPWR _4865_/S sky130_fd_sc_hd__buf_2
Xplace342 _5072_/A VGND VGND VPWR VPWR _3526_/B sky130_fd_sc_hd__buf_2
X_4992_ _4620_/C _4991_/Y _5020_/A VGND VGND VPWR VPWR _4992_/Y sky130_fd_sc_hd__a21oi_2
XFILLER_16_291 VGND VGND VPWR VPWR sky130_fd_sc_hd__decap_3
XFILLER_51_559 VGND VGND VPWR VPWR sky130_fd_sc_hd__fill_1
Xplace386 _5194_/B VGND VGND VPWR VPWR _5217_/B sky130_fd_sc_hd__buf_2
Xplace397 _3560_/Y VGND VGND VPWR VPWR _3562_/B sky130_fd_sc_hd__buf_2
Xplace375 _3709_/B1 VGND VGND VPWR VPWR _4466_/A sky130_fd_sc_hd__buf_2
X_6731_ _6959_/CLK _6731_/D VGND VGND VPWR VPWR _6731_/Q sky130_fd_sc_hd__dfxtp_2
X_3943_ _7368_/Q _4486_/A0 _3958_/S VGND VGND VPWR VPWR _7368_/D sky130_fd_sc_hd__mux2_2
XFILLER_31_250 VGND VGND VPWR VPWR sky130_fd_sc_hd__decap_3
X_6662_ _6686_/A VGND VGND VPWR VPWR _6662_/Y sky130_fd_sc_hd__inv_2
X_3874_ _5104_/A _3874_/B VGND VGND VPWR VPWR _3874_/X sky130_fd_sc_hd__or2_2
Xclkbuf_3_2__f_clk clkbuf_0_clk/X VGND VGND VPWR VPWR clkbuf_3_2__f_clk/X sky130_fd_sc_hd__clkbuf_16
X_5613_ _5613_/A _5633_/B VGND VGND VPWR VPWR _7021_/D sky130_fd_sc_hd__or2_2
X_6593_ _6635_/A VGND VGND VPWR VPWR _6593_/Y sky130_fd_sc_hd__inv_2
XFILLER_105_517 VGND VGND VPWR VPWR sky130_fd_sc_hd__decap_3
XFILLER_105_528 VGND VGND VPWR VPWR sky130_fd_sc_hd__decap_3
X_7214_ _7372_/CLK _7214_/D _6494_/Y VGND VGND VPWR VPWR _7214_/Q sky130_fd_sc_hd__dfrtp_2
X_4426_ _4446_/A _4426_/B VGND VGND VPWR VPWR _4813_/A sky130_fd_sc_hd__or2_2
XFILLER_59_604 VGND VGND VPWR VPWR sky130_fd_sc_hd__decap_3
X_7145_ _7403_/CLK _7145_/D _6425_/Y VGND VGND VPWR VPWR _7145_/Q sky130_fd_sc_hd__dfrtp_2
XFILLER_58_103 VGND VGND VPWR VPWR sky130_fd_sc_hd__decap_3
XFILLER_59_626 VGND VGND VPWR VPWR sky130_fd_sc_hd__decap_3
X_4357_ _4352_/X _4356_/X _4327_/A VGND VGND VPWR VPWR _4367_/C sky130_fd_sc_hd__o21ai_2
XFILLER_113_594 VGND VGND VPWR VPWR sky130_fd_sc_hd__decap_3
XFILLER_58_125 VGND VGND VPWR VPWR sky130_fd_sc_hd__decap_3
XFILLER_58_147 VGND VGND VPWR VPWR sky130_fd_sc_hd__decap_3
XFILLER_59_659 VGND VGND VPWR VPWR sky130_fd_sc_hd__decap_3
XFILLER_74_607 VGND VGND VPWR VPWR sky130_fd_sc_hd__decap_3
X_7076_ _7330_/CLK _7076_/D _6356_/Y VGND VGND VPWR VPWR _7076_/Q sky130_fd_sc_hd__dfrtp_2
X_4288_ _4394_/A _4337_/B _4288_/C _4288_/D VGND VGND VPWR VPWR _4288_/X sky130_fd_sc_hd__or4_4
X_3308_ _3369_/A _3362_/A VGND VGND VPWR VPWR _5118_/C sky130_fd_sc_hd__nand2_2
XFILLER_104_12 VGND VGND VPWR VPWR sky130_fd_sc_hd__decap_3
XFILLER_46_309 VGND VGND VPWR VPWR sky130_fd_sc_hd__decap_3
XFILLER_67_670 VGND VGND VPWR VPWR sky130_fd_sc_hd__fill_2
XFILLER_104_78 VGND VGND VPWR VPWR sky130_fd_sc_hd__fill_1
XFILLER_64_27 VGND VGND VPWR VPWR sky130_fd_sc_hd__fill_1
XFILLER_27_556 VGND VGND VPWR VPWR sky130_fd_sc_hd__decap_3
XFILLER_64_38 VGND VGND VPWR VPWR sky130_fd_sc_hd__decap_3
XFILLER_82_651 VGND VGND VPWR VPWR sky130_fd_sc_hd__decap_3
XFILLER_14_206 VGND VGND VPWR VPWR sky130_fd_sc_hd__decap_3
XFILLER_54_386 VGND VGND VPWR VPWR sky130_fd_sc_hd__decap_3
XFILLER_81_183 VGND VGND VPWR VPWR sky130_fd_sc_hd__decap_3
XFILLER_82_684 VGND VGND VPWR VPWR sky130_fd_sc_hd__decap_3
XTAP_TAPCELL_ROW_64_1018 VGND VPWR sky130_fd_sc_hd__tapvpwrvgnd_1
XFILLER_14_239 VGND VGND VPWR VPWR sky130_fd_sc_hd__decap_3
Xfanout21 _6632_/A VGND VGND VPWR VPWR _6599_/A sky130_fd_sc_hd__buf_2
X_6929_ _6929_/CLK _6929_/D VGND VGND VPWR VPWR _6929_/Q sky130_fd_sc_hd__dfxtp_2
XFILLER_10_401 VGND VGND VPWR VPWR sky130_fd_sc_hd__decap_3
XFILLER_22_250 VGND VGND VPWR VPWR sky130_fd_sc_hd__fill_2
XFILLER_80_26 VGND VGND VPWR VPWR sky130_fd_sc_hd__fill_2
Xfanout32 _6576_/A VGND VGND VPWR VPWR _6604_/A sky130_fd_sc_hd__buf_2
Xfanout43 fanout51/X VGND VGND VPWR VPWR _6547_/A sky130_fd_sc_hd__clkdlybuf4s25_1
Xfanout54 _6674_/A VGND VGND VPWR VPWR _6670_/A sky130_fd_sc_hd__clkdlybuf4s25_1
Xfanout65 _6619_/A VGND VGND VPWR VPWR _6647_/A sky130_fd_sc_hd__buf_2
XTAP_TAPCELL_ROW_40_727 VGND VPWR sky130_fd_sc_hd__tapvpwrvgnd_1
XFILLER_13_20 VGND VGND VPWR VPWR sky130_fd_sc_hd__decap_3
XFILLER_50_581 VGND VGND VPWR VPWR sky130_fd_sc_hd__decap_3
XFILLER_80_59 VGND VGND VPWR VPWR sky130_fd_sc_hd__decap_3
XFILLER_13_53 VGND VGND VPWR VPWR sky130_fd_sc_hd__decap_3
XFILLER_6_438 VGND VGND VPWR VPWR sky130_fd_sc_hd__fill_2
XFILLER_108_355 VGND VGND VPWR VPWR sky130_fd_sc_hd__decap_3
XFILLER_108_377 VGND VGND VPWR VPWR sky130_fd_sc_hd__decap_3
XFILLER_89_35 VGND VGND VPWR VPWR sky130_fd_sc_hd__decap_3
XFILLER_89_57 VGND VGND VPWR VPWR sky130_fd_sc_hd__decap_3
XTAP_TAPCELL_ROW_20_495 VGND VPWR sky130_fd_sc_hd__tapvpwrvgnd_1
XFILLER_2_600 VGND VGND VPWR VPWR sky130_fd_sc_hd__decap_3
XFILLER_2_633 VGND VGND VPWR VPWR sky130_fd_sc_hd__decap_3
XTAP_TAPCELL_ROW_75_1147 VGND VPWR sky130_fd_sc_hd__tapvpwrvgnd_1
XFILLER_1_143 VGND VGND VPWR VPWR sky130_fd_sc_hd__decap_3
XFILLER_2_666 VGND VGND VPWR VPWR sky130_fd_sc_hd__decap_3
XFILLER_77_434 VGND VGND VPWR VPWR sky130_fd_sc_hd__decap_3
XFILLER_38_61 VGND VGND VPWR VPWR sky130_fd_sc_hd__decap_3
XFILLER_64_106 VGND VGND VPWR VPWR sky130_fd_sc_hd__decap_3
XFILLER_65_629 VGND VGND VPWR VPWR sky130_fd_sc_hd__decap_3
XFILLER_77_467 VGND VGND VPWR VPWR sky130_fd_sc_hd__decap_3
XTAP_TAPCELL_ROW_48_827 VGND VPWR sky130_fd_sc_hd__tapvpwrvgnd_1
XFILLER_45_320 VGND VGND VPWR VPWR sky130_fd_sc_hd__decap_3
XFILLER_57_180 VGND VGND VPWR VPWR sky130_fd_sc_hd__decap_3
XFILLER_58_681 VGND VGND VPWR VPWR sky130_fd_sc_hd__decap_3
XFILLER_92_437 VGND VGND VPWR VPWR sky130_fd_sc_hd__decap_3
XFILLER_92_459 VGND VGND VPWR VPWR sky130_fd_sc_hd__fill_2
Xhold1190 _7159_/Q VGND VGND VPWR VPWR _5344_/A0 sky130_fd_sc_hd__dlygate4sd3_1
XFILLER_45_397 VGND VGND VPWR VPWR sky130_fd_sc_hd__decap_3
XFILLER_60_312 VGND VGND VPWR VPWR sky130_fd_sc_hd__decap_3
XFILLER_73_673 VGND VGND VPWR VPWR sky130_fd_sc_hd__decap_3
XTAP_TAPCELL_ROW_86_1287 VGND VPWR sky130_fd_sc_hd__tapvpwrvgnd_1
XTAP_TAPCELL_ROW_28_584 VGND VPWR sky130_fd_sc_hd__tapvpwrvgnd_1
XFILLER_54_71 VGND VGND VPWR VPWR sky130_fd_sc_hd__decap_3
XFILLER_60_345 VGND VGND VPWR VPWR sky130_fd_sc_hd__decap_3
XFILLER_72_194 VGND VGND VPWR VPWR sky130_fd_sc_hd__fill_2
XFILLER_13_261 VGND VGND VPWR VPWR sky130_fd_sc_hd__decap_3
XFILLER_60_389 VGND VGND VPWR VPWR sky130_fd_sc_hd__fill_2
XFILLER_70_70 VGND VGND VPWR VPWR sky130_fd_sc_hd__decap_3
Xclkload13 _6929_/CLK VGND VGND VPWR VPWR clkload13/Y sky130_fd_sc_hd__clkinv_2
Xclkload24 _7397_/CLK VGND VGND VPWR VPWR clkload24/X sky130_fd_sc_hd__clkbuf_8
Xclkload35 _7403_/CLK VGND VGND VPWR VPWR clkload35/Y sky130_fd_sc_hd__clkinv_2
X_3590_ _3590_/A _3590_/B _3590_/C VGND VGND VPWR VPWR _3620_/C sky130_fd_sc_hd__and3_2
XFILLER_114_303 VGND VGND VPWR VPWR sky130_fd_sc_hd__decap_3
XFILLER_5_460 VGND VGND VPWR VPWR sky130_fd_sc_hd__decap_3
X_5260_ _5260_/A0 _4964_/X _5274_/S VGND VGND VPWR VPWR _7200_/D sky130_fd_sc_hd__mux2_2
XFILLER_48_3 VGND VGND VPWR VPWR sky130_fd_sc_hd__decap_3
XFILLER_79_90 VGND VGND VPWR VPWR sky130_fd_sc_hd__decap_3
XFILLER_87_209 VGND VGND VPWR VPWR sky130_fd_sc_hd__decap_3
X_4211_ _4633_/A _4143_/X _4206_/X _4384_/A _4210_/X VGND VGND VPWR VPWR _4778_/A
+ sky130_fd_sc_hd__a221oi_2
XFILLER_68_401 VGND VGND VPWR VPWR sky130_fd_sc_hd__fill_1
XFILLER_110_531 VGND VGND VPWR VPWR sky130_fd_sc_hd__fill_1
XFILLER_68_434 VGND VGND VPWR VPWR sky130_fd_sc_hd__decap_3
X_4142_ _4142_/A _4142_/B _4142_/C VGND VGND VPWR VPWR _4142_/X sky130_fd_sc_hd__and3_2
XFILLER_55_106 VGND VGND VPWR VPWR sky130_fd_sc_hd__fill_2
XFILLER_56_618 VGND VGND VPWR VPWR sky130_fd_sc_hd__decap_3
XFILLER_68_489 VGND VGND VPWR VPWR sky130_fd_sc_hd__decap_3
X_4073_ _7275_/Q _4437_/A2 _4070_/X _4072_/X VGND VGND VPWR VPWR _4073_/X sky130_fd_sc_hd__a211o_2
XFILLER_110_586 VGND VGND VPWR VPWR sky130_fd_sc_hd__fill_2
XFILLER_48_180 VGND VGND VPWR VPWR sky130_fd_sc_hd__fill_2
XFILLER_64_640 VGND VGND VPWR VPWR sky130_fd_sc_hd__decap_3
XFILLER_64_651 VGND VGND VPWR VPWR sky130_fd_sc_hd__decap_3
XFILLER_63_150 VGND VGND VPWR VPWR sky130_fd_sc_hd__decap_3
XFILLER_64_684 VGND VGND VPWR VPWR sky130_fd_sc_hd__decap_3
XFILLER_91_470 VGND VGND VPWR VPWR sky130_fd_sc_hd__decap_3
XFILLER_51_323 VGND VGND VPWR VPWR sky130_fd_sc_hd__decap_3
XFILLER_51_356 VGND VGND VPWR VPWR sky130_fd_sc_hd__decap_3
X_4975_ _5015_/A _4975_/B VGND VGND VPWR VPWR _4975_/Y sky130_fd_sc_hd__nand2_2
X_6714_ _7401_/CLK _6714_/D VGND VGND VPWR VPWR _6714_/Q sky130_fd_sc_hd__dfxtp_2
X_3926_ _6913_/Q _3926_/A2 _3926_/B1 _6777_/Q _3925_/X VGND VGND VPWR VPWR _3926_/X
+ sky130_fd_sc_hd__a221o_2
XFILLER_32_581 VGND VGND VPWR VPWR sky130_fd_sc_hd__decap_3
XFILLER_50_29 VGND VGND VPWR VPWR sky130_fd_sc_hd__decap_3
Xclkload7 clkload7/A VGND VGND VPWR VPWR clkload7/X sky130_fd_sc_hd__clkbuf_16
X_6645_ _6675_/A VGND VGND VPWR VPWR _6645_/Y sky130_fd_sc_hd__inv_2
X_3857_ hold980/X _3909_/A2 _3856_/X VGND VGND VPWR VPWR _7387_/D sky130_fd_sc_hd__a21o_2
X_6576_ _6576_/A VGND VGND VPWR VPWR _6576_/Y sky130_fd_sc_hd__inv_2
X_3788_ _3741_/X _3785_/X _3787_/X _3735_/X VGND VGND VPWR VPWR _3788_/X sky130_fd_sc_hd__a22o_2
XFILLER_3_408 VGND VGND VPWR VPWR sky130_fd_sc_hd__decap_3
Xoutput551 _6986_/Q VGND VGND VPWR VPWR pc_out[9] sky130_fd_sc_hd__clkdlybuf4s25_1
Xoutput540 _7005_/Q VGND VGND VPWR VPWR pc_out[28] sky130_fd_sc_hd__clkdlybuf4s25_1
XFILLER_115_11 VGND VGND VPWR VPWR sky130_fd_sc_hd__decap_3
XFILLER_59_412 VGND VGND VPWR VPWR sky130_fd_sc_hd__decap_3
X_4409_ _4425_/A _4409_/B VGND VGND VPWR VPWR _4411_/B sky130_fd_sc_hd__nand2_2
XFILLER_99_581 VGND VGND VPWR VPWR sky130_fd_sc_hd__decap_3
XFILLER_101_520 VGND VGND VPWR VPWR sky130_fd_sc_hd__decap_3
XFILLER_113_391 VGND VGND VPWR VPWR sky130_fd_sc_hd__fill_1
XFILLER_115_44 VGND VGND VPWR VPWR sky130_fd_sc_hd__decap_3
XFILLER_59_445 VGND VGND VPWR VPWR sky130_fd_sc_hd__decap_3
XFILLER_86_220 VGND VGND VPWR VPWR sky130_fd_sc_hd__decap_3
X_7128_ clkload6/A _7128_/D _6408_/Y VGND VGND VPWR VPWR _7128_/Q sky130_fd_sc_hd__dfrtp_2
XFILLER_101_553 VGND VGND VPWR VPWR sky130_fd_sc_hd__decap_3
XFILLER_115_66 VGND VGND VPWR VPWR sky130_fd_sc_hd__decap_3
XFILLER_47_629 VGND VGND VPWR VPWR sky130_fd_sc_hd__decap_3
XFILLER_86_242 VGND VGND VPWR VPWR sky130_fd_sc_hd__decap_3
XFILLER_86_253 VGND VGND VPWR VPWR sky130_fd_sc_hd__decap_3
X_7059_ clkload8/A _7059_/D _6339_/Y VGND VGND VPWR VPWR _7059_/Q sky130_fd_sc_hd__dfrtp_2
XTAP_TAPCELL_ROW_70_1088 VGND VPWR sky130_fd_sc_hd__tapvpwrvgnd_1
XFILLER_101_586 VGND VGND VPWR VPWR sky130_fd_sc_hd__decap_3
XFILLER_115_99 VGND VGND VPWR VPWR sky130_fd_sc_hd__decap_3
XFILLER_46_139 VGND VGND VPWR VPWR sky130_fd_sc_hd__fill_1
XFILLER_74_448 VGND VGND VPWR VPWR sky130_fd_sc_hd__decap_3
XFILLER_55_662 VGND VGND VPWR VPWR sky130_fd_sc_hd__decap_3
XFILLER_27_386 VGND VGND VPWR VPWR sky130_fd_sc_hd__decap_3
XFILLER_54_150 VGND VGND VPWR VPWR sky130_fd_sc_hd__decap_3
XFILLER_55_673 VGND VGND VPWR VPWR sky130_fd_sc_hd__decap_3
XFILLER_61_109 VGND VGND VPWR VPWR sky130_fd_sc_hd__decap_3
XFILLER_15_559 VGND VGND VPWR VPWR sky130_fd_sc_hd__fill_1
XFILLER_42_323 VGND VGND VPWR VPWR sky130_fd_sc_hd__decap_3
XFILLER_54_183 VGND VGND VPWR VPWR sky130_fd_sc_hd__decap_3
XFILLER_82_492 VGND VGND VPWR VPWR sky130_fd_sc_hd__decap_3
XFILLER_24_41 VGND VGND VPWR VPWR sky130_fd_sc_hd__decap_3
XFILLER_42_378 VGND VGND VPWR VPWR sky130_fd_sc_hd__decap_3
XTAP_TAPCELL_ROW_53_885 VGND VPWR sky130_fd_sc_hd__tapvpwrvgnd_1
XTAP_TAPCELL_ROW_25_554 VGND VPWR sky130_fd_sc_hd__tapvpwrvgnd_1
XFILLER_24_63 VGND VGND VPWR VPWR sky130_fd_sc_hd__decap_3
XFILLER_10_231 VGND VGND VPWR VPWR sky130_fd_sc_hd__decap_3
XFILLER_10_253 VGND VGND VPWR VPWR sky130_fd_sc_hd__decap_3
XFILLER_109_620 VGND VGND VPWR VPWR sky130_fd_sc_hd__decap_3
XFILLER_6_235 VGND VGND VPWR VPWR sky130_fd_sc_hd__decap_3
XFILLER_108_141 VGND VGND VPWR VPWR sky130_fd_sc_hd__decap_3
XFILLER_109_653 VGND VGND VPWR VPWR sky130_fd_sc_hd__decap_3
XFILLER_10_297 VGND VGND VPWR VPWR sky130_fd_sc_hd__decap_3
XFILLER_2_430 VGND VGND VPWR VPWR sky130_fd_sc_hd__decap_3
XFILLER_111_328 VGND VGND VPWR VPWR sky130_fd_sc_hd__fill_2
XFILLER_104_380 VGND VGND VPWR VPWR sky130_fd_sc_hd__decap_3
XFILLER_77_231 VGND VGND VPWR VPWR sky130_fd_sc_hd__fill_1
XFILLER_1_23 VGND VGND VPWR VPWR sky130_fd_sc_hd__decap_3
XFILLER_38_618 VGND VGND VPWR VPWR sky130_fd_sc_hd__decap_3
XTAP_TAPCELL_ROW_88_1305 VGND VPWR sky130_fd_sc_hd__tapvpwrvgnd_1
XFILLER_77_297 VGND VGND VPWR VPWR sky130_fd_sc_hd__decap_3
XFILLER_1_78 VGND VGND VPWR VPWR sky130_fd_sc_hd__decap_3
XFILLER_46_651 VGND VGND VPWR VPWR sky130_fd_sc_hd__decap_3
XFILLER_80_407 VGND VGND VPWR VPWR sky130_fd_sc_hd__decap_3
XFILLER_92_256 VGND VGND VPWR VPWR sky130_fd_sc_hd__decap_3
XFILLER_18_386 VGND VGND VPWR VPWR sky130_fd_sc_hd__decap_3
XFILLER_33_312 VGND VGND VPWR VPWR sky130_fd_sc_hd__fill_2
XFILLER_45_150 VGND VGND VPWR VPWR sky130_fd_sc_hd__fill_2
XFILLER_45_161 VGND VGND VPWR VPWR sky130_fd_sc_hd__decap_3
XFILLER_45_172 VGND VGND VPWR VPWR sky130_fd_sc_hd__decap_3
XFILLER_46_684 VGND VGND VPWR VPWR sky130_fd_sc_hd__decap_3
XFILLER_65_92 VGND VGND VPWR VPWR sky130_fd_sc_hd__decap_3
XFILLER_73_470 VGND VGND VPWR VPWR sky130_fd_sc_hd__decap_3
XFILLER_61_632 VGND VGND VPWR VPWR sky130_fd_sc_hd__decap_3
XFILLER_60_153 VGND VGND VPWR VPWR sky130_fd_sc_hd__decap_3
XFILLER_61_665 VGND VGND VPWR VPWR sky130_fd_sc_hd__decap_3
XFILLER_61_676 VGND VGND VPWR VPWR sky130_fd_sc_hd__decap_3
X_4760_ _4777_/A _4760_/B VGND VGND VPWR VPWR _4760_/Y sky130_fd_sc_hd__nand2_2
X_4691_ _7004_/Q _4665_/X _4804_/A _4757_/A VGND VGND VPWR VPWR _4749_/B sky130_fd_sc_hd__a31o_2
X_3711_ _3746_/A VGND VGND VPWR VPWR _3735_/A sky130_fd_sc_hd__inv_2
XTAP_TAPCELL_ROW_99_1445 VGND VPWR sky130_fd_sc_hd__tapvpwrvgnd_1
XTAP_TAPCELL_ROW_99_1434 VGND VPWR sky130_fd_sc_hd__tapvpwrvgnd_1
XPHY_EDGE_ROW_112_Right_112 VGND VGND VPWR VPWR sky130_fd_sc_hd__decap_3
X_6430_ _6652_/A VGND VGND VPWR VPWR _6430_/Y sky130_fd_sc_hd__inv_2
X_3642_ _6718_/Q _6808_/Q _6896_/Q _6944_/Q _3991_/B _3665_/B VGND VGND VPWR VPWR
+ _3642_/X sky130_fd_sc_hd__mux4_2
X_6361_ _6385_/A VGND VGND VPWR VPWR _6361_/Y sky130_fd_sc_hd__inv_2
XFILLER_114_100 VGND VGND VPWR VPWR sky130_fd_sc_hd__decap_3
XFILLER_115_612 VGND VGND VPWR VPWR sky130_fd_sc_hd__decap_3
XFILLER_115_623 VGND VGND VPWR VPWR sky130_fd_sc_hd__decap_3
X_5312_ _5312_/A0 _4864_/X _5327_/S VGND VGND VPWR VPWR _7174_/D sky130_fd_sc_hd__mux2_2
X_3573_ _7316_/Q _3979_/S _4528_/B _7284_/Q VGND VGND VPWR VPWR _3573_/X sky130_fd_sc_hd__a22o_2
XPHY_EDGE_ROW_49_Right_49 VGND VGND VPWR VPWR sky130_fd_sc_hd__decap_3
XFILLER_114_133 VGND VGND VPWR VPWR sky130_fd_sc_hd__decap_3
XFILLER_114_144 VGND VGND VPWR VPWR sky130_fd_sc_hd__decap_3
XFILLER_115_656 VGND VGND VPWR VPWR sky130_fd_sc_hd__decap_3
XFILLER_5_290 VGND VGND VPWR VPWR sky130_fd_sc_hd__fill_1
X_6292_ _6637_/A VGND VGND VPWR VPWR _6292_/Y sky130_fd_sc_hd__inv_2
XFILLER_102_306 VGND VGND VPWR VPWR sky130_fd_sc_hd__fill_2
XFILLER_114_177 VGND VGND VPWR VPWR sky130_fd_sc_hd__decap_3
X_5243_ _5243_/A0 _4822_/X _5262_/S VGND VGND VPWR VPWR _7208_/D sky130_fd_sc_hd__mux2_2
XFILLER_68_231 VGND VGND VPWR VPWR sky130_fd_sc_hd__decap_3
XFILLER_56_404 VGND VGND VPWR VPWR sky130_fd_sc_hd__fill_1
XFILLER_68_253 VGND VGND VPWR VPWR sky130_fd_sc_hd__decap_3
XFILLER_96_573 VGND VGND VPWR VPWR sky130_fd_sc_hd__decap_3
X_4125_ _4205_/A _4117_/B _4117_/C _4124_/B VGND VGND VPWR VPWR _4125_/X sky130_fd_sc_hd__a31o_2
XFILLER_110_361 VGND VGND VPWR VPWR sky130_fd_sc_hd__decap_3
XFILLER_110_372 VGND VGND VPWR VPWR sky130_fd_sc_hd__decap_3
XFILLER_28_106 VGND VGND VPWR VPWR sky130_fd_sc_hd__decap_3
XFILLER_96_595 VGND VGND VPWR VPWR sky130_fd_sc_hd__decap_3
XFILLER_45_18 VGND VGND VPWR VPWR sky130_fd_sc_hd__decap_3
XFILLER_83_256 VGND VGND VPWR VPWR sky130_fd_sc_hd__decap_3
X_4056_ _7340_/Q _3947_/S _4428_/B1 _7148_/Q VGND VGND VPWR VPWR _4056_/X sky130_fd_sc_hd__a22o_2
XPHY_EDGE_ROW_58_Right_58 VGND VGND VPWR VPWR sky130_fd_sc_hd__decap_3
XFILLER_52_610 VGND VGND VPWR VPWR sky130_fd_sc_hd__decap_3
XTAP_TAPCELL_ROW_108_1552 VGND VPWR sky130_fd_sc_hd__tapvpwrvgnd_1
XFILLER_36_172 VGND VGND VPWR VPWR sky130_fd_sc_hd__fill_1
XFILLER_36_183 VGND VGND VPWR VPWR sky130_fd_sc_hd__decap_3
XFILLER_52_643 VGND VGND VPWR VPWR sky130_fd_sc_hd__fill_1
XFILLER_52_654 VGND VGND VPWR VPWR sky130_fd_sc_hd__decap_3
XFILLER_101_35 VGND VGND VPWR VPWR sky130_fd_sc_hd__decap_3
XFILLER_51_153 VGND VGND VPWR VPWR sky130_fd_sc_hd__decap_3
XFILLER_52_687 VGND VGND VPWR VPWR sky130_fd_sc_hd__decap_3
XFILLER_24_389 VGND VGND VPWR VPWR sky130_fd_sc_hd__decap_3
XFILLER_51_175 VGND VGND VPWR VPWR sky130_fd_sc_hd__fill_2
XFILLER_61_28 VGND VGND VPWR VPWR sky130_fd_sc_hd__decap_3
X_4958_ _4983_/B VGND VGND VPWR VPWR _4958_/Y sky130_fd_sc_hd__inv_2
XTAP_TAPCELL_ROW_22_513 VGND VPWR sky130_fd_sc_hd__tapvpwrvgnd_1
X_4889_ _4890_/B _4889_/B VGND VGND VPWR VPWR _4889_/Y sky130_fd_sc_hd__xnor2_2
X_3909_ hold977/X _3909_/A2 _3908_/X VGND VGND VPWR VPWR _7379_/D sky130_fd_sc_hd__a21o_2
XTAP_TAPCELL_ROW_50_855 VGND VPWR sky130_fd_sc_hd__tapvpwrvgnd_1
XFILLER_20_562 VGND VGND VPWR VPWR sky130_fd_sc_hd__decap_3
X_6628_ _6635_/A VGND VGND VPWR VPWR _6628_/Y sky130_fd_sc_hd__inv_2
XPHY_EDGE_ROW_67_Right_67 VGND VGND VPWR VPWR sky130_fd_sc_hd__decap_3
XFILLER_106_634 VGND VGND VPWR VPWR sky130_fd_sc_hd__decap_3
XFILLER_10_21 VGND VGND VPWR VPWR sky130_fd_sc_hd__decap_3
X_6559_ _6637_/A VGND VGND VPWR VPWR _6559_/Y sky130_fd_sc_hd__inv_2
XFILLER_106_645 VGND VGND VPWR VPWR sky130_fd_sc_hd__decap_3
XFILLER_10_32 VGND VGND VPWR VPWR sky130_fd_sc_hd__decap_3
XFILLER_3_249 VGND VGND VPWR VPWR sky130_fd_sc_hd__decap_3
XFILLER_106_678 VGND VGND VPWR VPWR sky130_fd_sc_hd__decap_3
XFILLER_10_65 VGND VGND VPWR VPWR sky130_fd_sc_hd__decap_3
XTAP_TAPCELL_ROW_72_1117 VGND VPWR sky130_fd_sc_hd__tapvpwrvgnd_1
XFILLER_59_220 VGND VGND VPWR VPWR sky130_fd_sc_hd__decap_3
XFILLER_59_264 VGND VGND VPWR VPWR sky130_fd_sc_hd__decap_3
XFILLER_86_58 VGND VGND VPWR VPWR sky130_fd_sc_hd__decap_3
XFILLER_101_372 VGND VGND VPWR VPWR sky130_fd_sc_hd__decap_3
XFILLER_19_41 VGND VGND VPWR VPWR sky130_fd_sc_hd__decap_3
XPHY_EDGE_ROW_76_Right_76 VGND VGND VPWR VPWR sky130_fd_sc_hd__decap_3
XFILLER_19_96 VGND VGND VPWR VPWR sky130_fd_sc_hd__decap_3
XFILLER_28_651 VGND VGND VPWR VPWR sky130_fd_sc_hd__decap_3
XFILLER_74_234 VGND VGND VPWR VPWR sky130_fd_sc_hd__fill_1
XFILLER_74_256 VGND VGND VPWR VPWR sky130_fd_sc_hd__fill_2
XTAP_TAPCELL_ROW_58_944 VGND VPWR sky130_fd_sc_hd__tapvpwrvgnd_1
XFILLER_27_150 VGND VGND VPWR VPWR sky130_fd_sc_hd__decap_3
XFILLER_28_662 VGND VGND VPWR VPWR sky130_fd_sc_hd__decap_3
XTAP_TAPCELL_ROW_2_271 VGND VPWR sky130_fd_sc_hd__tapvpwrvgnd_1
XFILLER_15_323 VGND VGND VPWR VPWR sky130_fd_sc_hd__decap_3
XFILLER_27_172 VGND VGND VPWR VPWR sky130_fd_sc_hd__decap_3
XFILLER_43_632 VGND VGND VPWR VPWR sky130_fd_sc_hd__decap_3
XFILLER_15_367 VGND VGND VPWR VPWR sky130_fd_sc_hd__fill_2
XFILLER_42_131 VGND VGND VPWR VPWR sky130_fd_sc_hd__fill_1
XFILLER_42_153 VGND VGND VPWR VPWR sky130_fd_sc_hd__decap_3
XFILLER_43_665 VGND VGND VPWR VPWR sky130_fd_sc_hd__decap_3
XFILLER_43_676 VGND VGND VPWR VPWR sky130_fd_sc_hd__decap_3
XFILLER_70_451 VGND VGND VPWR VPWR sky130_fd_sc_hd__decap_3
XTAP_TAPCELL_ROW_83_1246 VGND VPWR sky130_fd_sc_hd__tapvpwrvgnd_1
XFILLER_30_315 VGND VGND VPWR VPWR sky130_fd_sc_hd__fill_2
XFILLER_30_326 VGND VGND VPWR VPWR sky130_fd_sc_hd__decap_3
XFILLER_42_197 VGND VGND VPWR VPWR sky130_fd_sc_hd__decap_3
XFILLER_11_540 VGND VGND VPWR VPWR sky130_fd_sc_hd__fill_1
XPHY_EDGE_ROW_85_Right_85 VGND VGND VPWR VPWR sky130_fd_sc_hd__decap_3
XFILLER_51_94 VGND VGND VPWR VPWR sky130_fd_sc_hd__decap_3
XFILLER_7_544 VGND VGND VPWR VPWR sky130_fd_sc_hd__decap_3
XFILLER_109_461 VGND VGND VPWR VPWR sky130_fd_sc_hd__decap_3
XTAP_TAPCELL_ROW_94_1375 VGND VPWR sky130_fd_sc_hd__tapvpwrvgnd_1
XFILLER_112_604 VGND VGND VPWR VPWR sky130_fd_sc_hd__decap_3
XFILLER_111_125 VGND VGND VPWR VPWR sky130_fd_sc_hd__decap_3
XFILLER_112_637 VGND VGND VPWR VPWR sky130_fd_sc_hd__decap_3
XFILLER_112_648 VGND VGND VPWR VPWR sky130_fd_sc_hd__decap_3
XFILLER_2_271 VGND VGND VPWR VPWR sky130_fd_sc_hd__fill_2
XFILLER_32_6 VGND VGND VPWR VPWR sky130_fd_sc_hd__fill_2
XFILLER_97_348 VGND VGND VPWR VPWR sky130_fd_sc_hd__decap_3
XPHY_EDGE_ROW_29_Left_146 VGND VGND VPWR VPWR sky130_fd_sc_hd__decap_3
XFILLER_111_169 VGND VGND VPWR VPWR sky130_fd_sc_hd__decap_3
XFILLER_78_551 VGND VGND VPWR VPWR sky130_fd_sc_hd__decap_3
XPHY_EDGE_ROW_94_Right_94 VGND VGND VPWR VPWR sky130_fd_sc_hd__decap_3
XFILLER_65_223 VGND VGND VPWR VPWR sky130_fd_sc_hd__fill_1
XFILLER_78_584 VGND VGND VPWR VPWR sky130_fd_sc_hd__decap_3
XFILLER_65_234 VGND VGND VPWR VPWR sky130_fd_sc_hd__decap_3
XFILLER_76_91 VGND VGND VPWR VPWR sky130_fd_sc_hd__fill_2
XFILLER_93_543 VGND VGND VPWR VPWR sky130_fd_sc_hd__decap_3
XFILLER_18_150 VGND VGND VPWR VPWR sky130_fd_sc_hd__fill_2
XFILLER_46_470 VGND VGND VPWR VPWR sky130_fd_sc_hd__decap_3
XFILLER_53_429 VGND VGND VPWR VPWR sky130_fd_sc_hd__decap_3
XFILLER_93_598 VGND VGND VPWR VPWR sky130_fd_sc_hd__fill_1
XFILLER_18_183 VGND VGND VPWR VPWR sky130_fd_sc_hd__decap_3
XFILLER_46_492 VGND VGND VPWR VPWR sky130_fd_sc_hd__fill_1
XFILLER_33_175 VGND VGND VPWR VPWR sky130_fd_sc_hd__decap_3
X_4812_ _4827_/A _4827_/B VGND VGND VPWR VPWR _4812_/Y sky130_fd_sc_hd__nor2_2
XPHY_EDGE_ROW_38_Left_155 VGND VGND VPWR VPWR sky130_fd_sc_hd__decap_3
XFILLER_21_359 VGND VGND VPWR VPWR sky130_fd_sc_hd__decap_3
X_4743_ _4745_/A _4081_/X _4741_/X _4742_/Y VGND VGND VPWR VPWR _4743_/X sky130_fd_sc_hd__a31o_2
XTAP_TAPCELL_ROW_103_1493 VGND VPWR sky130_fd_sc_hd__tapvpwrvgnd_1
XTAP_TAPCELL_ROW_103_1482 VGND VPWR sky130_fd_sc_hd__tapvpwrvgnd_1
X_6413_ _6604_/A VGND VGND VPWR VPWR _6413_/Y sky130_fd_sc_hd__inv_2
X_4674_ _6989_/Q _4677_/B VGND VGND VPWR VPWR _4674_/X sky130_fd_sc_hd__or2_2
X_7393_ _7401_/CLK _7393_/D _6673_/Y VGND VGND VPWR VPWR _7393_/Q sky130_fd_sc_hd__dfrtp_2
X_3625_ _3618_/X _3619_/Y _3620_/X _3624_/X VGND VGND VPWR VPWR _3625_/X sky130_fd_sc_hd__a31o_2
X_6344_ _6347_/A VGND VGND VPWR VPWR _6344_/Y sky130_fd_sc_hd__inv_2
X_3556_ _3556_/A _3556_/B _3556_/C VGND VGND VPWR VPWR _3556_/X sky130_fd_sc_hd__or3_2
XFILLER_103_604 VGND VGND VPWR VPWR sky130_fd_sc_hd__fill_1
XFILLER_88_315 VGND VGND VPWR VPWR sky130_fd_sc_hd__decap_3
X_6275_ _6395_/A VGND VGND VPWR VPWR _6275_/Y sky130_fd_sc_hd__inv_2
XPHY_EDGE_ROW_47_Left_164 VGND VGND VPWR VPWR sky130_fd_sc_hd__decap_3
XFILLER_102_103 VGND VGND VPWR VPWR sky130_fd_sc_hd__decap_3
XFILLER_103_648 VGND VGND VPWR VPWR sky130_fd_sc_hd__decap_3
XFILLER_88_337 VGND VGND VPWR VPWR sky130_fd_sc_hd__decap_3
XFILLER_88_359 VGND VGND VPWR VPWR sky130_fd_sc_hd__decap_3
X_3487_ _3469_/A _3469_/B _3449_/A _7247_/Q _3365_/A VGND VGND VPWR VPWR _3487_/X
+ sky130_fd_sc_hd__o2111a_2
X_5157_ _5157_/A0 _5156_/X _5159_/S VGND VGND VPWR VPWR _7248_/D sky130_fd_sc_hd__mux2_2
XFILLER_56_256 VGND VGND VPWR VPWR sky130_fd_sc_hd__decap_3
X_5088_ _5086_/A _4365_/X _5086_/X _5087_/Y _5020_/A VGND VGND VPWR VPWR _5088_/X
+ sky130_fd_sc_hd__a2111o_2
X_4108_ _4394_/A _4394_/B _4107_/X VGND VGND VPWR VPWR _4142_/C sky130_fd_sc_hd__or3b_2
XFILLER_112_23 VGND VGND VPWR VPWR sky130_fd_sc_hd__decap_3
XFILLER_16_109 VGND VGND VPWR VPWR sky130_fd_sc_hd__decap_3
XFILLER_44_418 VGND VGND VPWR VPWR sky130_fd_sc_hd__fill_2
XFILLER_56_289 VGND VGND VPWR VPWR sky130_fd_sc_hd__decap_3
XFILLER_84_598 VGND VGND VPWR VPWR sky130_fd_sc_hd__decap_3
X_4039_ _4039_/A _4458_/A VGND VGND VPWR VPWR _4040_/B sky130_fd_sc_hd__and2_2
XTAP_TAPCELL_ROW_55_914 VGND VPWR sky130_fd_sc_hd__tapvpwrvgnd_1
XFILLER_112_56 VGND VGND VPWR VPWR sky130_fd_sc_hd__decap_3
XFILLER_24_131 VGND VGND VPWR VPWR sky130_fd_sc_hd__decap_3
XFILLER_24_153 VGND VGND VPWR VPWR sky130_fd_sc_hd__decap_3
XPHY_EDGE_ROW_56_Left_173 VGND VGND VPWR VPWR sky130_fd_sc_hd__decap_3
XFILLER_12_315 VGND VGND VPWR VPWR sky130_fd_sc_hd__decap_3
XTAP_TAPCELL_ROW_35_671 VGND VPWR sky130_fd_sc_hd__tapvpwrvgnd_1
XFILLER_12_348 VGND VGND VPWR VPWR sky130_fd_sc_hd__decap_3
XFILLER_24_197 VGND VGND VPWR VPWR sky130_fd_sc_hd__decap_3
XFILLER_40_668 VGND VGND VPWR VPWR sky130_fd_sc_hd__decap_3
XFILLER_21_53 VGND VGND VPWR VPWR sky130_fd_sc_hd__decap_3
XPHY_EDGE_ROW_65_Left_182 VGND VGND VPWR VPWR sky130_fd_sc_hd__decap_3
XFILLER_97_24 VGND VGND VPWR VPWR sky130_fd_sc_hd__decap_3
XFILLER_106_497 VGND VGND VPWR VPWR sky130_fd_sc_hd__decap_3
XFILLER_79_337 VGND VGND VPWR VPWR sky130_fd_sc_hd__decap_3
XFILLER_97_57 VGND VGND VPWR VPWR sky130_fd_sc_hd__decap_3
XTAP_TAPCELL_ROW_7_341 VGND VPWR sky130_fd_sc_hd__tapvpwrvgnd_1
XTAP_TAPCELL_ROW_7_330 VGND VPWR sky130_fd_sc_hd__tapvpwrvgnd_1
XFILLER_102_681 VGND VGND VPWR VPWR sky130_fd_sc_hd__decap_3
XFILLER_47_212 VGND VGND VPWR VPWR sky130_fd_sc_hd__fill_2
XFILLER_94_318 VGND VGND VPWR VPWR sky130_fd_sc_hd__decap_3
XFILLER_47_245 VGND VGND VPWR VPWR sky130_fd_sc_hd__decap_3
XFILLER_75_532 VGND VGND VPWR VPWR sky130_fd_sc_hd__decap_3
XFILLER_47_289 VGND VGND VPWR VPWR sky130_fd_sc_hd__decap_3
XFILLER_62_215 VGND VGND VPWR VPWR sky130_fd_sc_hd__decap_3
XFILLER_90_513 VGND VGND VPWR VPWR sky130_fd_sc_hd__decap_3
XPHY_EDGE_ROW_74_Left_191 VGND VGND VPWR VPWR sky130_fd_sc_hd__decap_3
XFILLER_16_621 VGND VGND VPWR VPWR sky130_fd_sc_hd__decap_3
XFILLER_46_94 VGND VGND VPWR VPWR sky130_fd_sc_hd__fill_1
XFILLER_15_153 VGND VGND VPWR VPWR sky130_fd_sc_hd__decap_3
XFILLER_15_175 VGND VGND VPWR VPWR sky130_fd_sc_hd__decap_3
XFILLER_43_495 VGND VGND VPWR VPWR sky130_fd_sc_hd__fill_1
XFILLER_31_668 VGND VGND VPWR VPWR sky130_fd_sc_hd__decap_3
XFILLER_62_71 VGND VGND VPWR VPWR sky130_fd_sc_hd__decap_3
XFILLER_30_167 VGND VGND VPWR VPWR sky130_fd_sc_hd__decap_3
XFILLER_7_33 VGND VGND VPWR VPWR sky130_fd_sc_hd__decap_3
XTAP_TAPCELL_ROW_96_1404 VGND VPWR sky130_fd_sc_hd__tapvpwrvgnd_1
XFILLER_116_206 VGND VGND VPWR VPWR sky130_fd_sc_hd__decap_3
XFILLER_116_228 VGND VGND VPWR VPWR sky130_fd_sc_hd__decap_3
XFILLER_7_66 VGND VGND VPWR VPWR sky130_fd_sc_hd__decap_3
XFILLER_7_99 VGND VGND VPWR VPWR sky130_fd_sc_hd__decap_3
X_4390_ _7241_/Q _4433_/B _3945_/S _7209_/Q VGND VGND VPWR VPWR _4390_/X sky130_fd_sc_hd__a22o_2
X_3410_ _7219_/Q _4331_/A2 _4530_/S _7032_/Q VGND VGND VPWR VPWR _3410_/X sky130_fd_sc_hd__a22o_2
X_3341_ _3341_/A VGND VGND VPWR VPWR _5642_/A sky130_fd_sc_hd__inv_2
XFILLER_97_101 VGND VGND VPWR VPWR sky130_fd_sc_hd__fill_2
XFILLER_97_134 VGND VGND VPWR VPWR sky130_fd_sc_hd__decap_3
XFILLER_98_657 VGND VGND VPWR VPWR sky130_fd_sc_hd__decap_3
XFILLER_98_635 VGND VGND VPWR VPWR sky130_fd_sc_hd__decap_3
XFILLER_112_445 VGND VGND VPWR VPWR sky130_fd_sc_hd__decap_3
XFILLER_112_467 VGND VGND VPWR VPWR sky130_fd_sc_hd__decap_3
XFILLER_112_489 VGND VGND VPWR VPWR sky130_fd_sc_hd__decap_3
XFILLER_38_212 VGND VGND VPWR VPWR sky130_fd_sc_hd__decap_3
XFILLER_78_381 VGND VGND VPWR VPWR sky130_fd_sc_hd__decap_3
XFILLER_85_318 VGND VGND VPWR VPWR sky130_fd_sc_hd__decap_3
XFILLER_87_90 VGND VGND VPWR VPWR sky130_fd_sc_hd__decap_3
Xhold1008 _7377_/Q VGND VGND VPWR VPWR _3920_/A1 sky130_fd_sc_hd__dlygate4sd3_1
Xhold1019 _7191_/Q VGND VGND VPWR VPWR _5278_/A0 sky130_fd_sc_hd__dlygate4sd3_1
X_5011_ _4836_/S _6991_/D _5010_/X VGND VGND VPWR VPWR _5011_/X sky130_fd_sc_hd__o21a_2
XFILLER_38_223 VGND VGND VPWR VPWR sky130_fd_sc_hd__decap_3
XFILLER_93_340 VGND VGND VPWR VPWR sky130_fd_sc_hd__decap_3
XFILLER_38_256 VGND VGND VPWR VPWR sky130_fd_sc_hd__decap_3
XFILLER_66_565 VGND VGND VPWR VPWR sky130_fd_sc_hd__decap_3
XFILLER_81_502 VGND VGND VPWR VPWR sky130_fd_sc_hd__fill_2
XFILLER_53_237 VGND VGND VPWR VPWR sky130_fd_sc_hd__decap_3
X_6962_ _6976_/CLK _6962_/D VGND VGND VPWR VPWR _6962_/Q sky130_fd_sc_hd__dfxtp_2
XTAP_TAPCELL_ROW_105_1511 VGND VPWR sky130_fd_sc_hd__tapvpwrvgnd_1
X_6893_ _7406_/CLK _6893_/D VGND VGND VPWR VPWR _6893_/Q sky130_fd_sc_hd__dfxtp_2
XFILLER_34_473 VGND VGND VPWR VPWR sky130_fd_sc_hd__decap_3
XFILLER_61_270 VGND VGND VPWR VPWR sky130_fd_sc_hd__decap_3
XFILLER_61_281 VGND VGND VPWR VPWR sky130_fd_sc_hd__decap_3
XTAP_TAPCELL_ROW_32_641 VGND VPWR sky130_fd_sc_hd__tapvpwrvgnd_1
XTAP_TAPCELL_ROW_32_630 VGND VPWR sky130_fd_sc_hd__tapvpwrvgnd_1
XFILLER_21_167 VGND VGND VPWR VPWR sky130_fd_sc_hd__fill_1
XTAP_TAPCELL_ROW_60_972 VGND VPWR sky130_fd_sc_hd__tapvpwrvgnd_1
X_4726_ _4799_/A _5655_/A _3670_/X _4467_/B VGND VGND VPWR VPWR _4726_/X sky130_fd_sc_hd__o211a_2
X_4657_ _4720_/A _4655_/X _4948_/A VGND VGND VPWR VPWR _4658_/B sky130_fd_sc_hd__a21oi_2
X_7376_ _7387_/CLK _7376_/D _6656_/Y VGND VGND VPWR VPWR _7376_/Q sky130_fd_sc_hd__dfrtp_2
Xhold820 _6764_/Q VGND VGND VPWR VPWR _6764_/D sky130_fd_sc_hd__dlygate4sd3_1
XTAP_TAPCELL_ROW_116_1651 VGND VPWR sky130_fd_sc_hd__tapvpwrvgnd_1
XTAP_TAPCELL_ROW_116_1640 VGND VPWR sky130_fd_sc_hd__tapvpwrvgnd_1
XFILLER_107_23 VGND VGND VPWR VPWR sky130_fd_sc_hd__decap_3
Xhold831 _6924_/Q VGND VGND VPWR VPWR _6924_/D sky130_fd_sc_hd__dlygate4sd3_1
Xhold842 _7089_/Q VGND VGND VPWR VPWR _7089_/D sky130_fd_sc_hd__dlygate4sd3_1
Xhold853 _7065_/Q VGND VGND VPWR VPWR _7065_/D sky130_fd_sc_hd__dlygate4sd3_1
Xhold864 _7082_/Q VGND VGND VPWR VPWR _7082_/D sky130_fd_sc_hd__dlygate4sd3_1
Xmax_cap572 _6483_/A VGND VGND VPWR VPWR _6522_/A sky130_fd_sc_hd__buf_4
Xmax_cap561 wire562/X VGND VGND VPWR VPWR _4275_/A sky130_fd_sc_hd__clkdlybuf4s25_1
X_6327_ _6675_/A VGND VGND VPWR VPWR _6327_/Y sky130_fd_sc_hd__inv_2
XFILLER_103_412 VGND VGND VPWR VPWR sky130_fd_sc_hd__decap_3
XFILLER_103_434 VGND VGND VPWR VPWR sky130_fd_sc_hd__decap_3
XFILLER_115_272 VGND VGND VPWR VPWR sky130_fd_sc_hd__decap_3
XFILLER_88_123 VGND VGND VPWR VPWR sky130_fd_sc_hd__decap_3
XFILLER_89_635 VGND VGND VPWR VPWR sky130_fd_sc_hd__decap_3
XFILLER_89_657 VGND VGND VPWR VPWR sky130_fd_sc_hd__decap_3
Xhold875 _7114_/Q VGND VGND VPWR VPWR _7114_/D sky130_fd_sc_hd__dlygate4sd3_1
Xhold886 _7083_/Q VGND VGND VPWR VPWR _7083_/D sky130_fd_sc_hd__dlygate4sd3_1
Xhold897 _7105_/Q VGND VGND VPWR VPWR _7105_/D sky130_fd_sc_hd__dlygate4sd3_1
X_3539_ _3544_/A _3544_/B VGND VGND VPWR VPWR _3547_/A sky130_fd_sc_hd__nand2_2
XFILLER_107_78 VGND VGND VPWR VPWR sky130_fd_sc_hd__decap_3
XFILLER_67_27 VGND VGND VPWR VPWR sky130_fd_sc_hd__decap_3
XFILLER_76_307 VGND VGND VPWR VPWR sky130_fd_sc_hd__fill_1
XFILLER_89_679 VGND VGND VPWR VPWR sky130_fd_sc_hd__decap_3
XTAP_TAPCELL_ROW_4_300 VGND VPWR sky130_fd_sc_hd__tapvpwrvgnd_1
XFILLER_103_478 VGND VGND VPWR VPWR sky130_fd_sc_hd__decap_3
XFILLER_69_370 VGND VGND VPWR VPWR sky130_fd_sc_hd__decap_3
XFILLER_76_318 VGND VGND VPWR VPWR sky130_fd_sc_hd__decap_3
XFILLER_88_189 VGND VGND VPWR VPWR sky130_fd_sc_hd__decap_3
X_5209_ _5209_/A _5225_/B VGND VGND VPWR VPWR _7224_/D sky130_fd_sc_hd__and2_2
XFILLER_29_245 VGND VGND VPWR VPWR sky130_fd_sc_hd__decap_3
XFILLER_83_48 VGND VGND VPWR VPWR sky130_fd_sc_hd__decap_3
XFILLER_16_53 VGND VGND VPWR VPWR sky130_fd_sc_hd__decap_3
XFILLER_13_635 VGND VGND VPWR VPWR sky130_fd_sc_hd__decap_3
XTAP_TAPCELL_ROW_80_1216 VGND VPWR sky130_fd_sc_hd__tapvpwrvgnd_1
XFILLER_16_97 VGND VGND VPWR VPWR sky130_fd_sc_hd__decap_3
XFILLER_40_421 VGND VGND VPWR VPWR sky130_fd_sc_hd__decap_3
XFILLER_9_606 VGND VGND VPWR VPWR sky130_fd_sc_hd__decap_3
XFILLER_40_465 VGND VGND VPWR VPWR sky130_fd_sc_hd__fill_1
XFILLER_9_628 VGND VGND VPWR VPWR sky130_fd_sc_hd__decap_3
XFILLER_12_189 VGND VGND VPWR VPWR sky130_fd_sc_hd__decap_3
XFILLER_32_41 VGND VGND VPWR VPWR sky130_fd_sc_hd__decap_3
XFILLER_32_74 VGND VGND VPWR VPWR sky130_fd_sc_hd__decap_3
XFILLER_8_138 VGND VGND VPWR VPWR sky130_fd_sc_hd__fill_2
XFILLER_32_85 VGND VGND VPWR VPWR sky130_fd_sc_hd__decap_3
XTAP_TAPCELL_ROW_10_368 VGND VPWR sky130_fd_sc_hd__tapvpwrvgnd_1
XFILLER_106_250 VGND VGND VPWR VPWR sky130_fd_sc_hd__fill_2
XTAP_TAPCELL_ROW_78_1189 VGND VPWR sky130_fd_sc_hd__tapvpwrvgnd_1
XFILLER_106_261 VGND VGND VPWR VPWR sky130_fd_sc_hd__fill_1
XTAP_TAPCELL_ROW_91_1345 VGND VPWR sky130_fd_sc_hd__tapvpwrvgnd_1
XFILLER_79_134 VGND VGND VPWR VPWR sky130_fd_sc_hd__decap_3
XFILLER_95_605 VGND VGND VPWR VPWR sky130_fd_sc_hd__decap_3
XFILLER_0_561 VGND VGND VPWR VPWR sky130_fd_sc_hd__fill_1
XFILLER_67_318 VGND VGND VPWR VPWR sky130_fd_sc_hd__decap_3
XFILLER_79_167 VGND VGND VPWR VPWR sky130_fd_sc_hd__fill_1
XFILLER_79_178 VGND VGND VPWR VPWR sky130_fd_sc_hd__decap_3
XFILLER_94_115 VGND VGND VPWR VPWR sky130_fd_sc_hd__decap_3
XFILLER_57_60 VGND VGND VPWR VPWR sky130_fd_sc_hd__decap_3
XFILLER_63_513 VGND VGND VPWR VPWR sky130_fd_sc_hd__decap_3
XFILLER_75_340 VGND VGND VPWR VPWR sky130_fd_sc_hd__decap_3
XFILLER_63_535 VGND VGND VPWR VPWR sky130_fd_sc_hd__decap_3
XFILLER_35_259 VGND VGND VPWR VPWR sky130_fd_sc_hd__decap_3
XFILLER_90_354 VGND VGND VPWR VPWR sky130_fd_sc_hd__decap_3
XFILLER_90_365 VGND VGND VPWR VPWR sky130_fd_sc_hd__fill_2
XTAP_TAPCELL_ROW_18_468 VGND VPWR sky130_fd_sc_hd__tapvpwrvgnd_1
XFILLER_16_462 VGND VGND VPWR VPWR sky130_fd_sc_hd__decap_3
XFILLER_73_70 VGND VGND VPWR VPWR sky130_fd_sc_hd__decap_3
XFILLER_73_81 VGND VGND VPWR VPWR sky130_fd_sc_hd__decap_3
XFILLER_90_376 VGND VGND VPWR VPWR sky130_fd_sc_hd__decap_3
XTAP_TAPCELL_ROW_46_799 VGND VPWR sky130_fd_sc_hd__tapvpwrvgnd_1
X_3890_ _6963_/Q _3892_/A2 _3893_/B1 _6945_/Q VGND VGND VPWR VPWR _3890_/X sky130_fd_sc_hd__a22o_2
XTAP_TAPCELL_ROW_100_1452 VGND VPWR sky130_fd_sc_hd__tapvpwrvgnd_1
X_7230_ _7230_/CLK _7230_/D _6510_/Y VGND VGND VPWR VPWR _7230_/Q sky130_fd_sc_hd__dfrtp_2
X_4442_ _4813_/A _4827_/A VGND VGND VPWR VPWR _4779_/A sky130_fd_sc_hd__or2_2
XFILLER_104_209 VGND VGND VPWR VPWR sky130_fd_sc_hd__decap_3
X_7161_ _7279_/CLK _7161_/D _6441_/Y VGND VGND VPWR VPWR _7161_/Q sky130_fd_sc_hd__dfrtp_2
X_4373_ _5018_/A _5018_/B VGND VGND VPWR VPWR _4373_/Y sky130_fd_sc_hd__nand2_2
XFILLER_98_432 VGND VGND VPWR VPWR sky130_fd_sc_hd__decap_3
XFILLER_98_410 VGND VGND VPWR VPWR sky130_fd_sc_hd__decap_3
X_7092_ clkload7/A _7092_/D _6372_/Y VGND VGND VPWR VPWR _7092_/Q sky130_fd_sc_hd__dfrtp_2
X_3324_ _3371_/A _4467_/A _4696_/B VGND VGND VPWR VPWR _3324_/X sky130_fd_sc_hd__or3_2
XFILLER_100_404 VGND VGND VPWR VPWR sky130_fd_sc_hd__fill_1
XFILLER_112_253 VGND VGND VPWR VPWR sky130_fd_sc_hd__fill_2
XFILLER_112_264 VGND VGND VPWR VPWR sky130_fd_sc_hd__decap_3
XFILLER_58_318 VGND VGND VPWR VPWR sky130_fd_sc_hd__decap_3
XFILLER_86_638 VGND VGND VPWR VPWR sky130_fd_sc_hd__decap_3
XTAP_TAPCELL_ROW_111_1581 VGND VPWR sky130_fd_sc_hd__tapvpwrvgnd_1
XFILLER_100_448 VGND VGND VPWR VPWR sky130_fd_sc_hd__fill_1
XFILLER_112_297 VGND VGND VPWR VPWR sky130_fd_sc_hd__decap_3
XFILLER_39_565 VGND VGND VPWR VPWR sky130_fd_sc_hd__fill_1
XFILLER_54_502 VGND VGND VPWR VPWR sky130_fd_sc_hd__decap_3
XFILLER_94_660 VGND VGND VPWR VPWR sky130_fd_sc_hd__decap_3
XTAP_TAPCELL_ROW_37_700 VGND VPWR sky130_fd_sc_hd__tapvpwrvgnd_1
XFILLER_66_384 VGND VGND VPWR VPWR sky130_fd_sc_hd__decap_3
XFILLER_81_332 VGND VGND VPWR VPWR sky130_fd_sc_hd__decap_3
XFILLER_26_248 VGND VGND VPWR VPWR sky130_fd_sc_hd__decap_3
XFILLER_26_259 VGND VGND VPWR VPWR sky130_fd_sc_hd__decap_3
XFILLER_53_18 VGND VGND VPWR VPWR sky130_fd_sc_hd__fill_2
XFILLER_81_343 VGND VGND VPWR VPWR sky130_fd_sc_hd__decap_3
X_6945_ _6972_/CLK _6945_/D VGND VGND VPWR VPWR _6945_/Q sky130_fd_sc_hd__dfxtp_2
XFILLER_22_410 VGND VGND VPWR VPWR sky130_fd_sc_hd__fill_2
XFILLER_41_207 VGND VGND VPWR VPWR sky130_fd_sc_hd__decap_3
XFILLER_41_218 VGND VGND VPWR VPWR sky130_fd_sc_hd__decap_3
XFILLER_81_376 VGND VGND VPWR VPWR sky130_fd_sc_hd__decap_3
XFILLER_22_421 VGND VGND VPWR VPWR sky130_fd_sc_hd__decap_3
X_6876_ _6931_/CLK _6876_/D VGND VGND VPWR VPWR _6876_/Q sky130_fd_sc_hd__dfxtp_2
XFILLER_10_605 VGND VGND VPWR VPWR sky130_fd_sc_hd__decap_3
XFILLER_5_108 VGND VGND VPWR VPWR sky130_fd_sc_hd__decap_3
XFILLER_5_119 VGND VGND VPWR VPWR sky130_fd_sc_hd__decap_3
X_4709_ _7002_/Q _7003_/Q _4826_/A VGND VGND VPWR VPWR _4801_/A sky130_fd_sc_hd__and3_2
XFILLER_116_592 VGND VGND VPWR VPWR sky130_fd_sc_hd__decap_3
XFILLER_78_26 VGND VGND VPWR VPWR sky130_fd_sc_hd__fill_2
X_7359_ _7397_/CLK _7359_/D _6639_/Y VGND VGND VPWR VPWR _7359_/Q sky130_fd_sc_hd__dfrtp_2
Xhold650 _6809_/Q VGND VGND VPWR VPWR _6809_/D sky130_fd_sc_hd__dlygate4sd3_1
Xhold661 _6800_/Q VGND VGND VPWR VPWR _6800_/D sky130_fd_sc_hd__dlygate4sd3_1
Xhold672 _6949_/Q VGND VGND VPWR VPWR _6949_/D sky130_fd_sc_hd__dlygate4sd3_1
XFILLER_103_220 VGND VGND VPWR VPWR sky130_fd_sc_hd__decap_3
XFILLER_103_231 VGND VGND VPWR VPWR sky130_fd_sc_hd__fill_1
XFILLER_89_465 VGND VGND VPWR VPWR sky130_fd_sc_hd__decap_3
Xhold683 _6940_/Q VGND VGND VPWR VPWR _6940_/D sky130_fd_sc_hd__dlygate4sd3_1
Xhold694 _6841_/Q VGND VGND VPWR VPWR _6841_/D sky130_fd_sc_hd__dlygate4sd3_1
XFILLER_103_275 VGND VGND VPWR VPWR sky130_fd_sc_hd__fill_2
XFILLER_77_638 VGND VGND VPWR VPWR sky130_fd_sc_hd__decap_3
XFILLER_94_36 VGND VGND VPWR VPWR sky130_fd_sc_hd__decap_3
XFILLER_94_58 VGND VGND VPWR VPWR sky130_fd_sc_hd__decap_3
XFILLER_17_237 VGND VGND VPWR VPWR sky130_fd_sc_hd__decap_3
XFILLER_45_546 VGND VGND VPWR VPWR sky130_fd_sc_hd__fill_1
XFILLER_72_321 VGND VGND VPWR VPWR sky130_fd_sc_hd__decap_3
XFILLER_84_170 VGND VGND VPWR VPWR sky130_fd_sc_hd__decap_3
XFILLER_85_682 VGND VGND VPWR VPWR sky130_fd_sc_hd__decap_3
XFILLER_27_74 VGND VGND VPWR VPWR sky130_fd_sc_hd__fill_2
XFILLER_72_365 VGND VGND VPWR VPWR sky130_fd_sc_hd__decap_3
XFILLER_84_192 VGND VGND VPWR VPWR sky130_fd_sc_hd__decap_3
XFILLER_32_218 VGND VGND VPWR VPWR sky130_fd_sc_hd__decap_3
XFILLER_60_516 VGND VGND VPWR VPWR sky130_fd_sc_hd__decap_3
XFILLER_25_281 VGND VGND VPWR VPWR sky130_fd_sc_hd__decap_3
XTAP_TAPCELL_ROW_43_769 VGND VPWR sky130_fd_sc_hd__tapvpwrvgnd_1
XTAP_TAPCELL_ROW_15_427 VGND VPWR sky130_fd_sc_hd__tapvpwrvgnd_1
XFILLER_13_476 VGND VGND VPWR VPWR sky130_fd_sc_hd__decap_3
XFILLER_43_51 VGND VGND VPWR VPWR sky130_fd_sc_hd__decap_3
XFILLER_40_295 VGND VGND VPWR VPWR sky130_fd_sc_hd__decap_3
XFILLER_9_469 VGND VGND VPWR VPWR sky130_fd_sc_hd__decap_3
XFILLER_64_9 VGND VGND VPWR VPWR sky130_fd_sc_hd__decap_3
XFILLER_114_507 VGND VGND VPWR VPWR sky130_fd_sc_hd__decap_3
XFILLER_4_130 VGND VGND VPWR VPWR sky130_fd_sc_hd__decap_3
XFILLER_4_141 VGND VGND VPWR VPWR sky130_fd_sc_hd__decap_3
XFILLER_5_664 VGND VGND VPWR VPWR sky130_fd_sc_hd__decap_3
XFILLER_107_570 VGND VGND VPWR VPWR sky130_fd_sc_hd__decap_3
XFILLER_4_12 VGND VGND VPWR VPWR sky130_fd_sc_hd__decap_3
XFILLER_4_56 VGND VGND VPWR VPWR sky130_fd_sc_hd__decap_3
XFILLER_68_605 VGND VGND VPWR VPWR sky130_fd_sc_hd__decap_3
XFILLER_68_81 VGND VGND VPWR VPWR sky130_fd_sc_hd__decap_3
XFILLER_95_413 VGND VGND VPWR VPWR sky130_fd_sc_hd__decap_3
XFILLER_0_391 VGND VGND VPWR VPWR sky130_fd_sc_hd__fill_1
XFILLER_48_340 VGND VGND VPWR VPWR sky130_fd_sc_hd__decap_3
XFILLER_48_362 VGND VGND VPWR VPWR sky130_fd_sc_hd__fill_2
XFILLER_76_660 VGND VGND VPWR VPWR sky130_fd_sc_hd__decap_3
XFILLER_95_479 VGND VGND VPWR VPWR sky130_fd_sc_hd__decap_3
XFILLER_63_310 VGND VGND VPWR VPWR sky130_fd_sc_hd__decap_3
XFILLER_75_181 VGND VGND VPWR VPWR sky130_fd_sc_hd__decap_3
XFILLER_82_118 VGND VGND VPWR VPWR sky130_fd_sc_hd__decap_3
XFILLER_63_343 VGND VGND VPWR VPWR sky130_fd_sc_hd__decap_3
XFILLER_84_80 VGND VGND VPWR VPWR sky130_fd_sc_hd__decap_3
Xplace321 _4356_/A2 VGND VGND VPWR VPWR _4601_/S sky130_fd_sc_hd__buf_2
Xplace310 _4561_/B VGND VGND VPWR VPWR _4567_/B sky130_fd_sc_hd__buf_2
XFILLER_51_516 VGND VGND VPWR VPWR sky130_fd_sc_hd__decap_3
XFILLER_63_376 VGND VGND VPWR VPWR sky130_fd_sc_hd__decap_3
XFILLER_90_151 VGND VGND VPWR VPWR sky130_fd_sc_hd__decap_3
XFILLER_91_685 VGND VGND VPWR VPWR sky130_fd_sc_hd__decap_3
Xplace354 _4879_/S VGND VGND VPWR VPWR _4772_/S sky130_fd_sc_hd__buf_2
Xplace343 _3618_/C VGND VGND VPWR VPWR _4764_/B sky130_fd_sc_hd__buf_2
Xplace332 _3407_/X VGND VGND VPWR VPWR _4351_/B1 sky130_fd_sc_hd__buf_2
X_6730_ _6977_/CLK _6730_/D VGND VGND VPWR VPWR _6730_/Q sky130_fd_sc_hd__dfxtp_2
X_4991_ _5004_/A _5004_/B _4988_/A VGND VGND VPWR VPWR _4991_/Y sky130_fd_sc_hd__a21oi_2
XFILLER_16_270 VGND VGND VPWR VPWR sky130_fd_sc_hd__decap_3
Xplace387 _5605_/B VGND VGND VPWR VPWR _5633_/B sky130_fd_sc_hd__buf_2
Xplace398 _4499_/S VGND VGND VPWR VPWR _4501_/S sky130_fd_sc_hd__buf_2
Xplace376 _3709_/B1 VGND VGND VPWR VPWR _5104_/A sky130_fd_sc_hd__buf_2
Xplace365 _4248_/A VGND VGND VPWR VPWR _4419_/C1 sky130_fd_sc_hd__buf_2
X_6661_ _6686_/A VGND VGND VPWR VPWR _6661_/Y sky130_fd_sc_hd__inv_2
X_3873_ _3733_/X _3870_/X _3872_/X _3923_/A1 VGND VGND VPWR VPWR _3874_/B sky130_fd_sc_hd__a22o_2
XFILLER_31_284 VGND VGND VPWR VPWR sky130_fd_sc_hd__decap_3
X_6592_ _6634_/A VGND VGND VPWR VPWR _6592_/Y sky130_fd_sc_hd__inv_2
X_7213_ _7372_/CLK _7213_/D _6493_/Y VGND VGND VPWR VPWR _7213_/Q sky130_fd_sc_hd__dfrtp_2
X_4425_ _4425_/A _4649_/B _4425_/C VGND VGND VPWR VPWR _4426_/B sky130_fd_sc_hd__and3_2
XTAP_TAPCELL_ROW_113_1610 VGND VPWR sky130_fd_sc_hd__tapvpwrvgnd_1
XFILLER_113_540 VGND VGND VPWR VPWR sky130_fd_sc_hd__decap_3
X_7144_ _7368_/CLK _7144_/D _6424_/Y VGND VGND VPWR VPWR _7144_/Q sky130_fd_sc_hd__dfrtp_2
X_4356_ _7012_/Q _4356_/A2 _4272_/B _7353_/Q _4355_/X VGND VGND VPWR VPWR _4356_/X
+ sky130_fd_sc_hd__a221o_2
XFILLER_48_29 VGND VGND VPWR VPWR sky130_fd_sc_hd__decap_3
XFILLER_59_638 VGND VGND VPWR VPWR sky130_fd_sc_hd__decap_3
XFILLER_86_424 VGND VGND VPWR VPWR sky130_fd_sc_hd__decap_3
XFILLER_98_251 VGND VGND VPWR VPWR sky130_fd_sc_hd__fill_1
XFILLER_100_234 VGND VGND VPWR VPWR sky130_fd_sc_hd__decap_3
XFILLER_86_457 VGND VGND VPWR VPWR sky130_fd_sc_hd__decap_3
X_7075_ _7266_/CLK _7075_/D _6355_/Y VGND VGND VPWR VPWR _7075_/Q sky130_fd_sc_hd__dfrtp_2
X_4287_ _7286_/Q _5159_/S _3409_/X _7158_/Q VGND VGND VPWR VPWR _4288_/D sky130_fd_sc_hd__a22o_2
XFILLER_100_256 VGND VGND VPWR VPWR sky130_fd_sc_hd__fill_1
XFILLER_104_24 VGND VGND VPWR VPWR sky130_fd_sc_hd__decap_3
XFILLER_104_35 VGND VGND VPWR VPWR sky130_fd_sc_hd__decap_3
XFILLER_58_159 VGND VGND VPWR VPWR sky130_fd_sc_hd__decap_3
XFILLER_73_107 VGND VGND VPWR VPWR sky130_fd_sc_hd__decap_3
XFILLER_27_535 VGND VGND VPWR VPWR sky130_fd_sc_hd__fill_2
XFILLER_54_321 VGND VGND VPWR VPWR sky130_fd_sc_hd__decap_3
XFILLER_66_181 VGND VGND VPWR VPWR sky130_fd_sc_hd__decap_3
XFILLER_67_682 VGND VGND VPWR VPWR sky130_fd_sc_hd__decap_3
XFILLER_82_630 VGND VGND VPWR VPWR sky130_fd_sc_hd__decap_3
XFILLER_82_663 VGND VGND VPWR VPWR sky130_fd_sc_hd__decap_3
XFILLER_14_218 VGND VGND VPWR VPWR sky130_fd_sc_hd__decap_3
XFILLER_27_579 VGND VGND VPWR VPWR sky130_fd_sc_hd__decap_3
XFILLER_42_505 VGND VGND VPWR VPWR sky130_fd_sc_hd__decap_3
XFILLER_81_151 VGND VGND VPWR VPWR sky130_fd_sc_hd__decap_3
XTAP_TAPCELL_ROW_64_1019 VGND VPWR sky130_fd_sc_hd__tapvpwrvgnd_1
XFILLER_54_398 VGND VGND VPWR VPWR sky130_fd_sc_hd__decap_3
Xfanout22 _6600_/A VGND VGND VPWR VPWR _6632_/A sky130_fd_sc_hd__clkdlybuf4s25_1
X_6928_ _6931_/CLK _6928_/D VGND VGND VPWR VPWR _6928_/Q sky130_fd_sc_hd__dfxtp_2
XFILLER_80_38 VGND VGND VPWR VPWR sky130_fd_sc_hd__decap_3
Xfanout33 fanout38/X VGND VGND VPWR VPWR _6606_/A sky130_fd_sc_hd__buf_1
Xfanout44 _6643_/A VGND VGND VPWR VPWR _6642_/A sky130_fd_sc_hd__buf_2
Xfanout55 _6684_/A VGND VGND VPWR VPWR _6674_/A sky130_fd_sc_hd__buf_2
X_6859_ _6964_/CLK _6859_/D VGND VGND VPWR VPWR _6859_/Q sky130_fd_sc_hd__dfxtp_2
XFILLER_13_32 VGND VGND VPWR VPWR sky130_fd_sc_hd__decap_3
XFILLER_22_284 VGND VGND VPWR VPWR sky130_fd_sc_hd__decap_3
Xfanout66 _6619_/A VGND VGND VPWR VPWR _6651_/A sky130_fd_sc_hd__buf_2
XTAP_TAPCELL_ROW_40_728 VGND VPWR sky130_fd_sc_hd__tapvpwrvgnd_1
XFILLER_10_446 VGND VGND VPWR VPWR sky130_fd_sc_hd__fill_1
XFILLER_6_406 VGND VGND VPWR VPWR sky130_fd_sc_hd__decap_3
XFILLER_108_312 VGND VGND VPWR VPWR sky130_fd_sc_hd__decap_3
XFILLER_13_87 VGND VGND VPWR VPWR sky130_fd_sc_hd__decap_3
XTAP_TAPCELL_ROW_20_496 VGND VPWR sky130_fd_sc_hd__tapvpwrvgnd_1
XFILLER_2_612 VGND VGND VPWR VPWR sky130_fd_sc_hd__decap_3
XFILLER_89_69 VGND VGND VPWR VPWR sky130_fd_sc_hd__decap_3
XTAP_TAPCELL_ROW_75_1148 VGND VPWR sky130_fd_sc_hd__tapvpwrvgnd_1
XFILLER_1_111 VGND VGND VPWR VPWR sky130_fd_sc_hd__fill_1
XFILLER_1_122 VGND VGND VPWR VPWR sky130_fd_sc_hd__decap_3
XFILLER_2_645 VGND VGND VPWR VPWR sky130_fd_sc_hd__decap_3
XFILLER_104_584 VGND VGND VPWR VPWR sky130_fd_sc_hd__decap_3
XFILLER_2_678 VGND VGND VPWR VPWR sky130_fd_sc_hd__decap_3
XFILLER_49_126 VGND VGND VPWR VPWR sky130_fd_sc_hd__fill_2
XFILLER_77_446 VGND VGND VPWR VPWR sky130_fd_sc_hd__fill_2
XFILLER_38_40 VGND VGND VPWR VPWR sky130_fd_sc_hd__decap_3
XFILLER_58_660 VGND VGND VPWR VPWR sky130_fd_sc_hd__decap_3
XFILLER_65_608 VGND VGND VPWR VPWR sky130_fd_sc_hd__decap_3
XFILLER_77_479 VGND VGND VPWR VPWR sky130_fd_sc_hd__decap_3
XFILLER_92_405 VGND VGND VPWR VPWR sky130_fd_sc_hd__decap_3
XFILLER_64_118 VGND VGND VPWR VPWR sky130_fd_sc_hd__decap_3
XFILLER_92_449 VGND VGND VPWR VPWR sky130_fd_sc_hd__decap_3
XTAP_TAPCELL_ROW_48_828 VGND VPWR sky130_fd_sc_hd__tapvpwrvgnd_1
XFILLER_73_641 VGND VGND VPWR VPWR sky130_fd_sc_hd__decap_3
XFILLER_73_663 VGND VGND VPWR VPWR sky130_fd_sc_hd__decap_3
Xhold1180 _7132_/Q VGND VGND VPWR VPWR _5402_/A0 sky130_fd_sc_hd__dlygate4sd3_1
Xhold1191 _7305_/Q VGND VGND VPWR VPWR _4550_/A sky130_fd_sc_hd__dlygate4sd3_1
XFILLER_33_505 VGND VGND VPWR VPWR sky130_fd_sc_hd__decap_3
XFILLER_54_50 VGND VGND VPWR VPWR sky130_fd_sc_hd__decap_3
XFILLER_72_151 VGND VGND VPWR VPWR sky130_fd_sc_hd__decap_3
XFILLER_72_173 VGND VGND VPWR VPWR sky130_fd_sc_hd__decap_3
XTAP_TAPCELL_ROW_86_1288 VGND VPWR sky130_fd_sc_hd__tapvpwrvgnd_1
XFILLER_33_538 VGND VGND VPWR VPWR sky130_fd_sc_hd__fill_2
XFILLER_54_83 VGND VGND VPWR VPWR sky130_fd_sc_hd__fill_1
XFILLER_60_324 VGND VGND VPWR VPWR sky130_fd_sc_hd__decap_3
XTAP_TAPCELL_ROW_28_585 VGND VPWR sky130_fd_sc_hd__tapvpwrvgnd_1
XFILLER_13_240 VGND VGND VPWR VPWR sky130_fd_sc_hd__decap_3
XFILLER_54_94 VGND VGND VPWR VPWR sky130_fd_sc_hd__decap_3
XFILLER_60_368 VGND VGND VPWR VPWR sky130_fd_sc_hd__decap_3
XFILLER_13_284 VGND VGND VPWR VPWR sky130_fd_sc_hd__decap_3
XFILLER_9_222 VGND VGND VPWR VPWR sky130_fd_sc_hd__fill_2
XFILLER_62_6 VGND VGND VPWR VPWR sky130_fd_sc_hd__decap_3
XFILLER_70_82 VGND VGND VPWR VPWR sky130_fd_sc_hd__fill_2
Xclkload14 _6911_/CLK VGND VGND VPWR VPWR clkload14/Y sky130_fd_sc_hd__clkinv_2
Xclkload25 _7401_/CLK VGND VGND VPWR VPWR clkload25/X sky130_fd_sc_hd__clkbuf_8
Xclkload36 _7369_/CLK VGND VGND VPWR VPWR clkload36/Y sky130_fd_sc_hd__clkinv_2
XFILLER_114_315 VGND VGND VPWR VPWR sky130_fd_sc_hd__decap_3
XFILLER_114_359 VGND VGND VPWR VPWR sky130_fd_sc_hd__decap_3
X_4210_ _4095_/A _4210_/B VGND VGND VPWR VPWR _4210_/X sky130_fd_sc_hd__and2b_2
XPHY_EDGE_ROW_10_Left_127 VGND VGND VPWR VPWR sky130_fd_sc_hd__decap_3
XFILLER_68_413 VGND VGND VPWR VPWR sky130_fd_sc_hd__decap_3
X_5190_ _5190_/A _5194_/B VGND VGND VPWR VPWR _7233_/D sky130_fd_sc_hd__and2_2
X_4141_ _4141_/A _4141_/B VGND VGND VPWR VPWR _4142_/B sky130_fd_sc_hd__nor2_2
XFILLER_110_554 VGND VGND VPWR VPWR sky130_fd_sc_hd__decap_3
XFILLER_95_265 VGND VGND VPWR VPWR sky130_fd_sc_hd__decap_3
X_4072_ _7243_/Q _4430_/A2 _4430_/B1 _7179_/Q _4071_/X VGND VGND VPWR VPWR _4072_/X
+ sky130_fd_sc_hd__a221o_2
XFILLER_110_598 VGND VGND VPWR VPWR sky130_fd_sc_hd__decap_3
XFILLER_49_671 VGND VGND VPWR VPWR sky130_fd_sc_hd__fill_1
XFILLER_49_682 VGND VGND VPWR VPWR sky130_fd_sc_hd__decap_3
XFILLER_83_449 VGND VGND VPWR VPWR sky130_fd_sc_hd__decap_3
XFILLER_95_90 VGND VGND VPWR VPWR sky130_fd_sc_hd__decap_3
XFILLER_36_332 VGND VGND VPWR VPWR sky130_fd_sc_hd__decap_3
XFILLER_64_663 VGND VGND VPWR VPWR sky130_fd_sc_hd__decap_3
XFILLER_36_365 VGND VGND VPWR VPWR sky130_fd_sc_hd__decap_3
XFILLER_63_162 VGND VGND VPWR VPWR sky130_fd_sc_hd__decap_3
XFILLER_63_173 VGND VGND VPWR VPWR sky130_fd_sc_hd__decap_3
XFILLER_36_398 VGND VGND VPWR VPWR sky130_fd_sc_hd__fill_1
XFILLER_51_346 VGND VGND VPWR VPWR sky130_fd_sc_hd__fill_1
XFILLER_63_195 VGND VGND VPWR VPWR sky130_fd_sc_hd__decap_3
X_4974_ _6993_/Q _4983_/B VGND VGND VPWR VPWR _4975_/B sky130_fd_sc_hd__xor2_2
X_6713_ _7406_/CLK _6713_/D VGND VGND VPWR VPWR _6713_/Q sky130_fd_sc_hd__dfxtp_2
X_3925_ _6687_/Q _3925_/A2 _3925_/B1 _6865_/Q VGND VGND VPWR VPWR _3925_/X sky130_fd_sc_hd__a22o_2
X_6644_ _6644_/A VGND VGND VPWR VPWR _6644_/Y sky130_fd_sc_hd__inv_2
XFILLER_50_19 VGND VGND VPWR VPWR sky130_fd_sc_hd__decap_3
Xclkload8 clkload8/A VGND VGND VPWR VPWR clkload8/Y sky130_fd_sc_hd__inv_4
X_3856_ _3845_/X _3855_/X _5138_/S VGND VGND VPWR VPWR _3856_/X sky130_fd_sc_hd__o21a_2
X_6575_ _6608_/A VGND VGND VPWR VPWR _6575_/Y sky130_fd_sc_hd__inv_2
X_3787_ _6739_/Q _3651_/Y _3891_/B1 _6745_/Q _3786_/X VGND VGND VPWR VPWR _3787_/X
+ sky130_fd_sc_hd__a221o_2
XFILLER_105_348 VGND VGND VPWR VPWR sky130_fd_sc_hd__fill_1
XFILLER_59_39 VGND VGND VPWR VPWR sky130_fd_sc_hd__decap_3
Xoutput541 _7006_/Q VGND VGND VPWR VPWR pc_out[29] sky130_fd_sc_hd__clkdlybuf4s25_1
Xoutput530 _6996_/Q VGND VGND VPWR VPWR pc_out[19] sky130_fd_sc_hd__clkdlybuf4s25_1
X_4408_ _7024_/Q _4408_/A2 _4404_/X _4407_/X VGND VGND VPWR VPWR _4409_/B sky130_fd_sc_hd__a211o_2
X_5388_ _5388_/A0 _4913_/X _5396_/S VGND VGND VPWR VPWR _7139_/D sky130_fd_sc_hd__mux2_2
XFILLER_101_532 VGND VGND VPWR VPWR sky130_fd_sc_hd__decap_3
XFILLER_115_23 VGND VGND VPWR VPWR sky130_fd_sc_hd__decap_3
XFILLER_59_424 VGND VGND VPWR VPWR sky130_fd_sc_hd__decap_3
X_7127_ clkload9/A _7127_/D _6407_/Y VGND VGND VPWR VPWR _7127_/Q sky130_fd_sc_hd__dfrtp_2
X_4339_ _7287_/Q _4530_/S _4339_/B1 _7159_/Q VGND VGND VPWR VPWR _4339_/X sky130_fd_sc_hd__a22o_2
XFILLER_115_78 VGND VGND VPWR VPWR sky130_fd_sc_hd__decap_3
XFILLER_47_608 VGND VGND VPWR VPWR sky130_fd_sc_hd__decap_3
XFILLER_75_16 VGND VGND VPWR VPWR sky130_fd_sc_hd__decap_3
XFILLER_86_265 VGND VGND VPWR VPWR sky130_fd_sc_hd__decap_3
X_7058_ clkload8/A _7058_/D _6338_/Y VGND VGND VPWR VPWR _7058_/Q sky130_fd_sc_hd__dfstp_2
XTAP_TAPCELL_ROW_70_1089 VGND VPWR sky130_fd_sc_hd__tapvpwrvgnd_1
XFILLER_27_310 VGND VGND VPWR VPWR sky130_fd_sc_hd__decap_3
XFILLER_46_107 VGND VGND VPWR VPWR sky130_fd_sc_hd__fill_1
XFILLER_74_438 VGND VGND VPWR VPWR sky130_fd_sc_hd__decap_3
XFILLER_75_49 VGND VGND VPWR VPWR sky130_fd_sc_hd__decap_3
XFILLER_86_276 VGND VGND VPWR VPWR sky130_fd_sc_hd__decap_3
XFILLER_86_287 VGND VGND VPWR VPWR sky130_fd_sc_hd__fill_2
XFILLER_86_298 VGND VGND VPWR VPWR sky130_fd_sc_hd__fill_2
XFILLER_39_181 VGND VGND VPWR VPWR sky130_fd_sc_hd__decap_3
XFILLER_55_641 VGND VGND VPWR VPWR sky130_fd_sc_hd__decap_3
XFILLER_15_505 VGND VGND VPWR VPWR sky130_fd_sc_hd__decap_3
XFILLER_27_365 VGND VGND VPWR VPWR sky130_fd_sc_hd__decap_3
XFILLER_55_685 VGND VGND VPWR VPWR sky130_fd_sc_hd__decap_3
XFILLER_70_611 VGND VGND VPWR VPWR sky130_fd_sc_hd__fill_1
XFILLER_82_471 VGND VGND VPWR VPWR sky130_fd_sc_hd__decap_3
XFILLER_91_15 VGND VGND VPWR VPWR sky130_fd_sc_hd__fill_1
XFILLER_15_538 VGND VGND VPWR VPWR sky130_fd_sc_hd__fill_1
XFILLER_42_335 VGND VGND VPWR VPWR sky130_fd_sc_hd__decap_3
XFILLER_24_20 VGND VGND VPWR VPWR sky130_fd_sc_hd__decap_3
XFILLER_42_368 VGND VGND VPWR VPWR sky130_fd_sc_hd__decap_3
XFILLER_70_688 VGND VGND VPWR VPWR sky130_fd_sc_hd__decap_3
XTAP_TAPCELL_ROW_25_555 VGND VPWR sky130_fd_sc_hd__tapvpwrvgnd_1
XTAP_TAPCELL_ROW_53_886 VGND VPWR sky130_fd_sc_hd__tapvpwrvgnd_1
XFILLER_10_243 VGND VGND VPWR VPWR sky130_fd_sc_hd__decap_3
XFILLER_109_610 VGND VGND VPWR VPWR sky130_fd_sc_hd__decap_3
XFILLER_109_632 VGND VGND VPWR VPWR sky130_fd_sc_hd__decap_3
XFILLER_10_265 VGND VGND VPWR VPWR sky130_fd_sc_hd__decap_3
XFILLER_108_131 VGND VGND VPWR VPWR sky130_fd_sc_hd__decap_3
XFILLER_109_665 VGND VGND VPWR VPWR sky130_fd_sc_hd__decap_3
XFILLER_109_676 VGND VGND VPWR VPWR sky130_fd_sc_hd__decap_3
XFILLER_40_52 VGND VGND VPWR VPWR sky130_fd_sc_hd__decap_3
XFILLER_40_85 VGND VGND VPWR VPWR sky130_fd_sc_hd__fill_2
XFILLER_108_197 VGND VGND VPWR VPWR sky130_fd_sc_hd__decap_3
XFILLER_97_508 VGND VGND VPWR VPWR sky130_fd_sc_hd__decap_3
XFILLER_2_442 VGND VGND VPWR VPWR sky130_fd_sc_hd__decap_3
XFILLER_104_392 VGND VGND VPWR VPWR sky130_fd_sc_hd__fill_1
XFILLER_27_9 VGND VGND VPWR VPWR sky130_fd_sc_hd__fill_2
XFILLER_65_405 VGND VGND VPWR VPWR sky130_fd_sc_hd__decap_3
XFILLER_77_265 VGND VGND VPWR VPWR sky130_fd_sc_hd__decap_3
XTAP_TAPCELL_ROW_88_1306 VGND VPWR sky130_fd_sc_hd__tapvpwrvgnd_1
XFILLER_1_35 VGND VGND VPWR VPWR sky130_fd_sc_hd__decap_3
XFILLER_37_107 VGND VGND VPWR VPWR sky130_fd_sc_hd__decap_3
XFILLER_37_129 VGND VGND VPWR VPWR sky130_fd_sc_hd__decap_3
XFILLER_65_438 VGND VGND VPWR VPWR sky130_fd_sc_hd__decap_3
XFILLER_18_321 VGND VGND VPWR VPWR sky130_fd_sc_hd__decap_3
XFILLER_1_57 VGND VGND VPWR VPWR sky130_fd_sc_hd__decap_3
XFILLER_46_630 VGND VGND VPWR VPWR sky130_fd_sc_hd__decap_3
XFILLER_65_449 VGND VGND VPWR VPWR sky130_fd_sc_hd__decap_3
XFILLER_18_354 VGND VGND VPWR VPWR sky130_fd_sc_hd__decap_3
XFILLER_46_663 VGND VGND VPWR VPWR sky130_fd_sc_hd__decap_3
XFILLER_61_611 VGND VGND VPWR VPWR sky130_fd_sc_hd__decap_3
XFILLER_65_71 VGND VGND VPWR VPWR sky130_fd_sc_hd__decap_3
XFILLER_80_419 VGND VGND VPWR VPWR sky130_fd_sc_hd__fill_1
XFILLER_92_268 VGND VGND VPWR VPWR sky130_fd_sc_hd__decap_3
XFILLER_45_195 VGND VGND VPWR VPWR sky130_fd_sc_hd__fill_1
XFILLER_61_644 VGND VGND VPWR VPWR sky130_fd_sc_hd__decap_3
XFILLER_73_482 VGND VGND VPWR VPWR sky130_fd_sc_hd__decap_3
XFILLER_21_519 VGND VGND VPWR VPWR sky130_fd_sc_hd__decap_3
XFILLER_61_688 VGND VGND VPWR VPWR sky130_fd_sc_hd__decap_3
XFILLER_14_560 VGND VGND VPWR VPWR sky130_fd_sc_hd__fill_2
X_3710_ _3710_/A1 _4832_/A _3709_/X VGND VGND VPWR VPWR _7399_/D sky130_fd_sc_hd__o21a_2
XFILLER_41_390 VGND VGND VPWR VPWR sky130_fd_sc_hd__fill_2
X_4690_ _7005_/Q _5605_/B VGND VGND VPWR VPWR _4757_/A sky130_fd_sc_hd__and2_2
XTAP_TAPCELL_ROW_99_1435 VGND VPWR sky130_fd_sc_hd__tapvpwrvgnd_1
XFILLER_60_3 VGND VGND VPWR VPWR sky130_fd_sc_hd__decap_3
X_6360_ _6388_/A VGND VGND VPWR VPWR _6360_/Y sky130_fd_sc_hd__inv_2
X_3572_ _4295_/B _3607_/B VGND VGND VPWR VPWR _4292_/A sky130_fd_sc_hd__xnor2_2
XFILLER_115_635 VGND VGND VPWR VPWR sky130_fd_sc_hd__decap_3
XFILLER_114_112 VGND VGND VPWR VPWR sky130_fd_sc_hd__decap_3
XFILLER_115_668 VGND VGND VPWR VPWR sky130_fd_sc_hd__decap_3
X_6291_ _6535_/A VGND VGND VPWR VPWR _6291_/Y sky130_fd_sc_hd__inv_2
XFILLER_114_156 VGND VGND VPWR VPWR sky130_fd_sc_hd__decap_3
XFILLER_115_679 VGND VGND VPWR VPWR sky130_fd_sc_hd__decap_3
XFILLER_102_329 VGND VGND VPWR VPWR sky130_fd_sc_hd__decap_3
XFILLER_114_189 VGND VGND VPWR VPWR sky130_fd_sc_hd__decap_3
X_5173_ _5173_/A _5182_/B VGND VGND VPWR VPWR _7241_/D sky130_fd_sc_hd__and2_2
XFILLER_68_265 VGND VGND VPWR VPWR sky130_fd_sc_hd__fill_2
XFILLER_96_552 VGND VGND VPWR VPWR sky130_fd_sc_hd__decap_3
X_4124_ _4117_/Y _4124_/B VGND VGND VPWR VPWR _4126_/A sky130_fd_sc_hd__and2b_2
XFILLER_110_384 VGND VGND VPWR VPWR sky130_fd_sc_hd__fill_1
XFILLER_28_118 VGND VGND VPWR VPWR sky130_fd_sc_hd__decap_3
XFILLER_56_416 VGND VGND VPWR VPWR sky130_fd_sc_hd__decap_3
XFILLER_68_276 VGND VGND VPWR VPWR sky130_fd_sc_hd__fill_1
XFILLER_68_298 VGND VGND VPWR VPWR sky130_fd_sc_hd__decap_3
XFILLER_83_213 VGND VGND VPWR VPWR sky130_fd_sc_hd__decap_3
XFILLER_96_585 VGND VGND VPWR VPWR sky130_fd_sc_hd__decap_3
XFILLER_37_630 VGND VGND VPWR VPWR sky130_fd_sc_hd__decap_3
XFILLER_83_235 VGND VGND VPWR VPWR sky130_fd_sc_hd__decap_3
X_4055_ _4055_/A _4658_/A VGND VGND VPWR VPWR _4720_/A sky130_fd_sc_hd__nor2b_2
XFILLER_36_151 VGND VGND VPWR VPWR sky130_fd_sc_hd__decap_3
XFILLER_71_408 VGND VGND VPWR VPWR sky130_fd_sc_hd__decap_3
XFILLER_83_268 VGND VGND VPWR VPWR sky130_fd_sc_hd__decap_3
XTAP_TAPCELL_ROW_108_1553 VGND VPWR sky130_fd_sc_hd__tapvpwrvgnd_1
XTAP_TAPCELL_ROW_108_1542 VGND VPWR sky130_fd_sc_hd__tapvpwrvgnd_1
XFILLER_101_14 VGND VGND VPWR VPWR sky130_fd_sc_hd__fill_2
XFILLER_52_622 VGND VGND VPWR VPWR sky130_fd_sc_hd__decap_3
XFILLER_24_346 VGND VGND VPWR VPWR sky130_fd_sc_hd__decap_3
XFILLER_52_666 VGND VGND VPWR VPWR sky130_fd_sc_hd__decap_3
X_4957_ _4982_/B _5009_/A _6992_/Q VGND VGND VPWR VPWR _4983_/B sky130_fd_sc_hd__o21ai_2
XTAP_TAPCELL_ROW_22_514 VGND VPWR sky130_fd_sc_hd__tapvpwrvgnd_1
XFILLER_20_530 VGND VGND VPWR VPWR sky130_fd_sc_hd__fill_2
X_4888_ _4888_/A _4888_/B VGND VGND VPWR VPWR _4889_/B sky130_fd_sc_hd__or2_2
X_3908_ _3728_/B _3907_/X _5138_/S VGND VGND VPWR VPWR _3908_/X sky130_fd_sc_hd__o21a_2
XTAP_TAPCELL_ROW_50_856 VGND VPWR sky130_fd_sc_hd__tapvpwrvgnd_1
X_6627_ _6664_/A VGND VGND VPWR VPWR _6627_/Y sky130_fd_sc_hd__inv_2
X_3839_ _3746_/X _3836_/X _3838_/X _3733_/X VGND VGND VPWR VPWR _3845_/A sky130_fd_sc_hd__a22o_2
X_6558_ _6558_/A VGND VGND VPWR VPWR _6558_/Y sky130_fd_sc_hd__inv_2
XFILLER_105_101 VGND VGND VPWR VPWR sky130_fd_sc_hd__decap_3
XFILLER_106_657 VGND VGND VPWR VPWR sky130_fd_sc_hd__decap_3
XFILLER_10_44 VGND VGND VPWR VPWR sky130_fd_sc_hd__decap_3
XFILLER_3_228 VGND VGND VPWR VPWR sky130_fd_sc_hd__decap_3
X_6489_ _6584_/A VGND VGND VPWR VPWR _6489_/Y sky130_fd_sc_hd__inv_2
XFILLER_105_156 VGND VGND VPWR VPWR sky130_fd_sc_hd__decap_3
XFILLER_10_77 VGND VGND VPWR VPWR sky130_fd_sc_hd__decap_3
XFILLER_79_508 VGND VGND VPWR VPWR sky130_fd_sc_hd__fill_1
XTAP_TAPCELL_ROW_72_1118 VGND VPWR sky130_fd_sc_hd__tapvpwrvgnd_1
XFILLER_114_690 VGND VGND VPWR VPWR sky130_fd_sc_hd__fill_2
XFILLER_99_390 VGND VGND VPWR VPWR sky130_fd_sc_hd__fill_2
XFILLER_19_20 VGND VGND VPWR VPWR sky130_fd_sc_hd__decap_3
XFILLER_59_243 VGND VGND VPWR VPWR sky130_fd_sc_hd__decap_3
XFILLER_87_541 VGND VGND VPWR VPWR sky130_fd_sc_hd__fill_2
XFILLER_101_384 VGND VGND VPWR VPWR sky130_fd_sc_hd__decap_3
XFILLER_19_53 VGND VGND VPWR VPWR sky130_fd_sc_hd__decap_3
XFILLER_19_64 VGND VGND VPWR VPWR sky130_fd_sc_hd__decap_3
XFILLER_59_276 VGND VGND VPWR VPWR sky130_fd_sc_hd__decap_3
XFILLER_59_287 VGND VGND VPWR VPWR sky130_fd_sc_hd__fill_1
XFILLER_28_641 VGND VGND VPWR VPWR sky130_fd_sc_hd__decap_3
Xclkbuf_leaf_39_clk clkload0/A VGND VGND VPWR VPWR _7322_/CLK sky130_fd_sc_hd__clkbuf_16
XTAP_TAPCELL_ROW_58_945 VGND VPWR sky130_fd_sc_hd__tapvpwrvgnd_1
XFILLER_15_302 VGND VGND VPWR VPWR sky130_fd_sc_hd__decap_3
XFILLER_27_162 VGND VGND VPWR VPWR sky130_fd_sc_hd__decap_3
XFILLER_55_460 VGND VGND VPWR VPWR sky130_fd_sc_hd__decap_3
XFILLER_74_268 VGND VGND VPWR VPWR sky130_fd_sc_hd__decap_3
XTAP_TAPCELL_ROW_2_272 VGND VPWR sky130_fd_sc_hd__tapvpwrvgnd_1
XFILLER_27_184 VGND VGND VPWR VPWR sky130_fd_sc_hd__decap_3
XFILLER_43_644 VGND VGND VPWR VPWR sky130_fd_sc_hd__decap_3
XFILLER_82_290 VGND VGND VPWR VPWR sky130_fd_sc_hd__decap_3
XTAP_TAPCELL_ROW_83_1247 VGND VPWR sky130_fd_sc_hd__tapvpwrvgnd_1
XFILLER_30_305 VGND VGND VPWR VPWR sky130_fd_sc_hd__decap_3
XFILLER_43_688 VGND VGND VPWR VPWR sky130_fd_sc_hd__fill_1
XFILLER_23_390 VGND VGND VPWR VPWR sky130_fd_sc_hd__fill_2
XFILLER_30_338 VGND VGND VPWR VPWR sky130_fd_sc_hd__decap_3
XFILLER_51_51 VGND VGND VPWR VPWR sky130_fd_sc_hd__decap_3
XFILLER_51_73 VGND VGND VPWR VPWR sky130_fd_sc_hd__decap_3
XFILLER_109_473 VGND VGND VPWR VPWR sky130_fd_sc_hd__fill_2
XFILLER_112_616 VGND VGND VPWR VPWR sky130_fd_sc_hd__decap_3
XFILLER_97_305 VGND VGND VPWR VPWR sky130_fd_sc_hd__fill_1
XTAP_TAPCELL_ROW_94_1376 VGND VPWR sky130_fd_sc_hd__tapvpwrvgnd_1
XFILLER_97_327 VGND VGND VPWR VPWR sky130_fd_sc_hd__decap_3
XFILLER_111_137 VGND VGND VPWR VPWR sky130_fd_sc_hd__decap_3
XFILLER_111_159 VGND VGND VPWR VPWR sky130_fd_sc_hd__decap_3
XFILLER_25_6 VGND VGND VPWR VPWR sky130_fd_sc_hd__decap_3
XFILLER_38_416 VGND VGND VPWR VPWR sky130_fd_sc_hd__decap_3
XFILLER_65_202 VGND VGND VPWR VPWR sky130_fd_sc_hd__decap_3
XFILLER_76_70 VGND VGND VPWR VPWR sky130_fd_sc_hd__decap_3
XFILLER_34_600 VGND VGND VPWR VPWR sky130_fd_sc_hd__decap_3
XFILLER_65_268 VGND VGND VPWR VPWR sky130_fd_sc_hd__decap_3
XFILLER_80_216 VGND VGND VPWR VPWR sky130_fd_sc_hd__decap_3
XFILLER_93_577 VGND VGND VPWR VPWR sky130_fd_sc_hd__decap_3
XFILLER_18_195 VGND VGND VPWR VPWR sky130_fd_sc_hd__fill_1
XFILLER_61_452 VGND VGND VPWR VPWR sky130_fd_sc_hd__fill_2
XFILLER_92_80 VGND VGND VPWR VPWR sky130_fd_sc_hd__decap_3
X_4811_ _4652_/B _4811_/B _4811_/C VGND VGND VPWR VPWR _4811_/X sky130_fd_sc_hd__and3b_2
XFILLER_21_305 VGND VGND VPWR VPWR sky130_fd_sc_hd__decap_3
XFILLER_21_316 VGND VGND VPWR VPWR sky130_fd_sc_hd__decap_3
XFILLER_33_187 VGND VGND VPWR VPWR sky130_fd_sc_hd__decap_3
XFILLER_61_485 VGND VGND VPWR VPWR sky130_fd_sc_hd__decap_3
XFILLER_92_91 VGND VGND VPWR VPWR sky130_fd_sc_hd__decap_3
X_4742_ _4745_/A _4081_/X _4454_/X _4969_/B VGND VGND VPWR VPWR _4742_/Y sky130_fd_sc_hd__o211ai_2
XTAP_TAPCELL_ROW_103_1483 VGND VPWR sky130_fd_sc_hd__tapvpwrvgnd_1
X_4673_ _4982_/B _4673_/B VGND VGND VPWR VPWR _4680_/A sky130_fd_sc_hd__or2_2
X_6412_ _6604_/A VGND VGND VPWR VPWR _6412_/Y sky130_fd_sc_hd__inv_2
X_3624_ _5072_/A _3600_/A _4614_/C _3635_/B VGND VGND VPWR VPWR _3624_/X sky130_fd_sc_hd__a22o_2
X_7392_ _7392_/CLK _7392_/D _6672_/Y VGND VGND VPWR VPWR _7392_/Q sky130_fd_sc_hd__dfrtp_2
X_6343_ _6347_/A VGND VGND VPWR VPWR _6343_/Y sky130_fd_sc_hd__inv_2
X_3555_ _7285_/Q _4532_/S _3366_/X _7157_/Q VGND VGND VPWR VPWR _3556_/C sky130_fd_sc_hd__a22o_2
XFILLER_0_209 VGND VGND VPWR VPWR sky130_fd_sc_hd__decap_3
X_6274_ _6523_/A VGND VGND VPWR VPWR _6274_/Y sky130_fd_sc_hd__inv_2
X_3486_ _3502_/A _3502_/B _3485_/C VGND VGND VPWR VPWR _5144_/B sky130_fd_sc_hd__o21ai_2
XFILLER_102_115 VGND VGND VPWR VPWR sky130_fd_sc_hd__fill_2
X_5225_ _5225_/A _5225_/B VGND VGND VPWR VPWR _7216_/D sky130_fd_sc_hd__and2_2
XFILLER_69_541 VGND VGND VPWR VPWR sky130_fd_sc_hd__decap_3
XFILLER_111_671 VGND VGND VPWR VPWR sky130_fd_sc_hd__fill_1
XFILLER_111_682 VGND VGND VPWR VPWR sky130_fd_sc_hd__decap_3
XFILLER_29_405 VGND VGND VPWR VPWR sky130_fd_sc_hd__decap_3
XFILLER_29_427 VGND VGND VPWR VPWR sky130_fd_sc_hd__decap_3
XFILLER_56_29 VGND VGND VPWR VPWR sky130_fd_sc_hd__decap_3
XFILLER_96_371 VGND VGND VPWR VPWR sky130_fd_sc_hd__decap_3
X_5156_ _7010_/D _5155_/X _5156_/S VGND VGND VPWR VPWR _5156_/X sky130_fd_sc_hd__mux2_2
XFILLER_29_449 VGND VGND VPWR VPWR sky130_fd_sc_hd__decap_3
XFILLER_56_235 VGND VGND VPWR VPWR sky130_fd_sc_hd__decap_3
XFILLER_84_555 VGND VGND VPWR VPWR sky130_fd_sc_hd__decap_3
X_5087_ _5101_/B _5100_/B _5086_/A _4365_/X VGND VGND VPWR VPWR _5087_/Y sky130_fd_sc_hd__a211oi_2
X_4107_ _7301_/Q _4879_/S _4434_/A2 _7109_/Q _4106_/X VGND VGND VPWR VPWR _4107_/X
+ sky130_fd_sc_hd__a221o_2
XFILLER_25_600 VGND VGND VPWR VPWR sky130_fd_sc_hd__fill_1
XFILLER_44_408 VGND VGND VPWR VPWR sky130_fd_sc_hd__decap_3
XFILLER_71_205 VGND VGND VPWR VPWR sky130_fd_sc_hd__decap_3
X_4038_ _4039_/A _4458_/A VGND VGND VPWR VPWR _4608_/B sky130_fd_sc_hd__nor2_2
XTAP_TAPCELL_ROW_55_915 VGND VPWR sky130_fd_sc_hd__tapvpwrvgnd_1
XFILLER_112_35 VGND VGND VPWR VPWR sky130_fd_sc_hd__decap_3
XFILLER_112_68 VGND VGND VPWR VPWR sky130_fd_sc_hd__decap_3
XFILLER_25_644 VGND VGND VPWR VPWR sky130_fd_sc_hd__decap_3
XFILLER_71_249 VGND VGND VPWR VPWR sky130_fd_sc_hd__decap_3
XTAP_TAPCELL_ROW_69_1080 VGND VPWR sky130_fd_sc_hd__tapvpwrvgnd_1
XFILLER_52_430 VGND VGND VPWR VPWR sky130_fd_sc_hd__decap_3
XFILLER_12_327 VGND VGND VPWR VPWR sky130_fd_sc_hd__decap_3
XFILLER_24_176 VGND VGND VPWR VPWR sky130_fd_sc_hd__decap_3
XTAP_TAPCELL_ROW_35_672 VGND VPWR sky130_fd_sc_hd__tapvpwrvgnd_1
XFILLER_21_32 VGND VGND VPWR VPWR sky130_fd_sc_hd__decap_3
XFILLER_4_504 VGND VGND VPWR VPWR sky130_fd_sc_hd__decap_3
XFILLER_106_421 VGND VGND VPWR VPWR sky130_fd_sc_hd__decap_3
XFILLER_108_3 VGND VGND VPWR VPWR sky130_fd_sc_hd__decap_3
XFILLER_106_443 VGND VGND VPWR VPWR sky130_fd_sc_hd__decap_3
XFILLER_106_465 VGND VGND VPWR VPWR sky130_fd_sc_hd__decap_3
XFILLER_97_36 VGND VGND VPWR VPWR sky130_fd_sc_hd__decap_3
XTAP_TAPCELL_ROW_7_331 VGND VPWR sky130_fd_sc_hd__tapvpwrvgnd_1
XFILLER_102_660 VGND VGND VPWR VPWR sky130_fd_sc_hd__decap_3
XFILLER_75_500 VGND VGND VPWR VPWR sky130_fd_sc_hd__decap_3
XFILLER_16_600 VGND VGND VPWR VPWR sky130_fd_sc_hd__decap_3
XFILLER_46_40 VGND VGND VPWR VPWR sky130_fd_sc_hd__decap_3
XFILLER_47_257 VGND VGND VPWR VPWR sky130_fd_sc_hd__fill_2
XFILLER_46_62 VGND VGND VPWR VPWR sky130_fd_sc_hd__decap_3
XFILLER_62_227 VGND VGND VPWR VPWR sky130_fd_sc_hd__decap_3
XFILLER_90_536 VGND VGND VPWR VPWR sky130_fd_sc_hd__decap_3
XFILLER_43_452 VGND VGND VPWR VPWR sky130_fd_sc_hd__decap_3
XFILLER_55_290 VGND VGND VPWR VPWR sky130_fd_sc_hd__decap_3
XFILLER_62_249 VGND VGND VPWR VPWR sky130_fd_sc_hd__decap_3
XFILLER_15_187 VGND VGND VPWR VPWR sky130_fd_sc_hd__decap_3
XFILLER_43_474 VGND VGND VPWR VPWR sky130_fd_sc_hd__fill_2
XFILLER_43_485 VGND VGND VPWR VPWR sky130_fd_sc_hd__fill_2
XFILLER_70_271 VGND VGND VPWR VPWR sky130_fd_sc_hd__decap_3
XFILLER_94_9 VGND VGND VPWR VPWR sky130_fd_sc_hd__decap_3
XFILLER_30_124 VGND VGND VPWR VPWR sky130_fd_sc_hd__decap_3
XFILLER_31_647 VGND VGND VPWR VPWR sky130_fd_sc_hd__fill_1
XFILLER_62_50 VGND VGND VPWR VPWR sky130_fd_sc_hd__decap_3
XFILLER_70_293 VGND VGND VPWR VPWR sky130_fd_sc_hd__decap_3
XFILLER_30_179 VGND VGND VPWR VPWR sky130_fd_sc_hd__decap_3
XFILLER_62_83 VGND VGND VPWR VPWR sky130_fd_sc_hd__fill_1
XFILLER_62_94 VGND VGND VPWR VPWR sky130_fd_sc_hd__decap_3
XFILLER_7_12 VGND VGND VPWR VPWR sky130_fd_sc_hd__decap_3
XFILLER_11_393 VGND VGND VPWR VPWR sky130_fd_sc_hd__decap_3
XFILLER_7_45 VGND VGND VPWR VPWR sky130_fd_sc_hd__decap_3
XTAP_TAPCELL_ROW_96_1405 VGND VPWR sky130_fd_sc_hd__tapvpwrvgnd_1
XFILLER_7_78 VGND VGND VPWR VPWR sky130_fd_sc_hd__decap_3
XFILLER_109_270 VGND VGND VPWR VPWR sky130_fd_sc_hd__decap_3
XFILLER_109_281 VGND VGND VPWR VPWR sky130_fd_sc_hd__decap_3
X_3340_ _5129_/A _3340_/B _3340_/C VGND VGND VPWR VPWR _5640_/B sky130_fd_sc_hd__and3_2
XFILLER_112_424 VGND VGND VPWR VPWR sky130_fd_sc_hd__decap_3
XFILLER_97_113 VGND VGND VPWR VPWR sky130_fd_sc_hd__decap_3
XFILLER_112_457 VGND VGND VPWR VPWR sky130_fd_sc_hd__decap_3
X_5010_ _5010_/A _5662_/A _5010_/C _5010_/D VGND VGND VPWR VPWR _5010_/X sky130_fd_sc_hd__or4_2
XFILLER_98_669 VGND VGND VPWR VPWR sky130_fd_sc_hd__decap_3
XFILLER_23_3 VGND VGND VPWR VPWR sky130_fd_sc_hd__decap_3
Xhold1009 _7203_/Q VGND VGND VPWR VPWR _5253_/A0 sky130_fd_sc_hd__dlygate4sd3_1
XFILLER_38_246 VGND VGND VPWR VPWR sky130_fd_sc_hd__decap_3
XFILLER_26_419 VGND VGND VPWR VPWR sky130_fd_sc_hd__fill_1
XFILLER_38_268 VGND VGND VPWR VPWR sky130_fd_sc_hd__decap_3
XFILLER_81_514 VGND VGND VPWR VPWR sky130_fd_sc_hd__decap_3
XFILLER_93_352 VGND VGND VPWR VPWR sky130_fd_sc_hd__decap_3
XFILLER_93_396 VGND VGND VPWR VPWR sky130_fd_sc_hd__decap_3
X_6961_ _6972_/CLK _6961_/D VGND VGND VPWR VPWR _6961_/Q sky130_fd_sc_hd__dfxtp_2
XTAP_TAPCELL_ROW_105_1512 VGND VPWR sky130_fd_sc_hd__tapvpwrvgnd_1
XFILLER_34_452 VGND VGND VPWR VPWR sky130_fd_sc_hd__decap_3
XFILLER_53_249 VGND VGND VPWR VPWR sky130_fd_sc_hd__decap_3
X_6892_ _7406_/CLK _6892_/D VGND VGND VPWR VPWR _6892_/Q sky130_fd_sc_hd__dfxtp_2
XFILLER_21_102 VGND VGND VPWR VPWR sky130_fd_sc_hd__fill_2
XFILLER_22_603 VGND VGND VPWR VPWR sky130_fd_sc_hd__fill_2
XFILLER_21_113 VGND VGND VPWR VPWR sky130_fd_sc_hd__decap_3
XFILLER_61_293 VGND VGND VPWR VPWR sky130_fd_sc_hd__decap_3
XTAP_TAPCELL_ROW_32_631 VGND VPWR sky130_fd_sc_hd__tapvpwrvgnd_1
XFILLER_21_146 VGND VGND VPWR VPWR sky130_fd_sc_hd__decap_3
XTAP_TAPCELL_ROW_60_973 VGND VPWR sky130_fd_sc_hd__tapvpwrvgnd_1
XFILLER_30_691 VGND VGND VPWR VPWR sky130_fd_sc_hd__fill_1
X_4725_ _4969_/B _4720_/X _4723_/X _4724_/X VGND VGND VPWR VPWR _5655_/A sky130_fd_sc_hd__a211o_2
X_7375_ _7387_/CLK _7375_/D _6655_/Y VGND VGND VPWR VPWR _7375_/Q sky130_fd_sc_hd__dfrtp_2
Xhold810 _6967_/Q VGND VGND VPWR VPWR _6967_/D sky130_fd_sc_hd__dlygate4sd3_1
Xhold821 _6958_/Q VGND VGND VPWR VPWR _6958_/D sky130_fd_sc_hd__dlygate4sd3_1
X_4587_ _7287_/Q _4595_/B VGND VGND VPWR VPWR _7287_/D sky130_fd_sc_hd__and2_2
X_3607_ _4295_/B _3607_/B VGND VGND VPWR VPWR _3610_/A sky130_fd_sc_hd__nand2_2
XTAP_TAPCELL_ROW_116_1652 VGND VPWR sky130_fd_sc_hd__tapvpwrvgnd_1
XTAP_TAPCELL_ROW_116_1641 VGND VPWR sky130_fd_sc_hd__tapvpwrvgnd_1
XPHY_EDGE_ROW_2_Left_119 VGND VGND VPWR VPWR sky130_fd_sc_hd__decap_3
XFILLER_115_240 VGND VGND VPWR VPWR sky130_fd_sc_hd__fill_2
Xhold832 _6827_/Q VGND VGND VPWR VPWR _6827_/D sky130_fd_sc_hd__dlygate4sd3_1
Xhold843 _7061_/Q VGND VGND VPWR VPWR _7061_/D sky130_fd_sc_hd__dlygate4sd3_1
Xhold854 _7068_/Q VGND VGND VPWR VPWR _7068_/D sky130_fd_sc_hd__dlygate4sd3_1
X_6326_ _6675_/A VGND VGND VPWR VPWR _6326_/Y sky130_fd_sc_hd__inv_2
X_3538_ _3424_/S _3456_/X _4537_/C _3421_/C VGND VGND VPWR VPWR _3544_/B sky130_fd_sc_hd__o2bb2a_2
XFILLER_107_35 VGND VGND VPWR VPWR sky130_fd_sc_hd__decap_3
XFILLER_107_57 VGND VGND VPWR VPWR sky130_fd_sc_hd__decap_3
XFILLER_115_284 VGND VGND VPWR VPWR sky130_fd_sc_hd__decap_3
XFILLER_89_647 VGND VGND VPWR VPWR sky130_fd_sc_hd__decap_3
Xhold865 _7055_/Q VGND VGND VPWR VPWR _7055_/D sky130_fd_sc_hd__dlygate4sd3_1
Xhold876 _7106_/Q VGND VGND VPWR VPWR _7106_/D sky130_fd_sc_hd__dlygate4sd3_1
Xhold887 _7080_/Q VGND VGND VPWR VPWR _7080_/D sky130_fd_sc_hd__dlygate4sd3_1
Xhold898 _7097_/Q VGND VGND VPWR VPWR _7097_/D sky130_fd_sc_hd__dlygate4sd3_1
Xmax_cap573 _6685_/A VGND VGND VPWR VPWR _6686_/A sky130_fd_sc_hd__buf_2
XFILLER_67_39 VGND VGND VPWR VPWR sky130_fd_sc_hd__decap_3
XFILLER_88_135 VGND VGND VPWR VPWR sky130_fd_sc_hd__decap_3
XFILLER_89_669 VGND VGND VPWR VPWR sky130_fd_sc_hd__decap_3
X_3469_ _3469_/A _3469_/B VGND VGND VPWR VPWR _4537_/C sky130_fd_sc_hd__nor2_2
XFILLER_29_202 VGND VGND VPWR VPWR sky130_fd_sc_hd__decap_3
XFILLER_57_500 VGND VGND VPWR VPWR sky130_fd_sc_hd__decap_3
XFILLER_57_511 VGND VGND VPWR VPWR sky130_fd_sc_hd__fill_2
XFILLER_88_168 VGND VGND VPWR VPWR sky130_fd_sc_hd__decap_3
XTAP_TAPCELL_ROW_4_301 VGND VPWR sky130_fd_sc_hd__tapvpwrvgnd_1
X_5139_ _4677_/B _5138_/X _5092_/C VGND VGND VPWR VPWR _5139_/X sky130_fd_sc_hd__o21a_2
XFILLER_97_691 VGND VGND VPWR VPWR sky130_fd_sc_hd__fill_1
XFILLER_29_257 VGND VGND VPWR VPWR sky130_fd_sc_hd__fill_1
XFILLER_29_279 VGND VGND VPWR VPWR sky130_fd_sc_hd__fill_1
XFILLER_44_238 VGND VGND VPWR VPWR sky130_fd_sc_hd__decap_3
XFILLER_16_21 VGND VGND VPWR VPWR sky130_fd_sc_hd__decap_3
XFILLER_16_32 VGND VGND VPWR VPWR sky130_fd_sc_hd__decap_3
XFILLER_72_558 VGND VGND VPWR VPWR sky130_fd_sc_hd__decap_3
XFILLER_16_65 VGND VGND VPWR VPWR sky130_fd_sc_hd__fill_1
XFILLER_52_271 VGND VGND VPWR VPWR sky130_fd_sc_hd__decap_3
XTAP_TAPCELL_ROW_80_1217 VGND VPWR sky130_fd_sc_hd__tapvpwrvgnd_1
XTAP_TAPCELL_ROW_80_1206 VGND VPWR sky130_fd_sc_hd__tapvpwrvgnd_1
XFILLER_40_455 VGND VGND VPWR VPWR sky130_fd_sc_hd__decap_3
XFILLER_40_477 VGND VGND VPWR VPWR sky130_fd_sc_hd__fill_1
XFILLER_21_691 VGND VGND VPWR VPWR sky130_fd_sc_hd__fill_1
XFILLER_32_53 VGND VGND VPWR VPWR sky130_fd_sc_hd__decap_3
XTAP_TAPCELL_ROW_10_369 VGND VPWR sky130_fd_sc_hd__tapvpwrvgnd_1
XFILLER_79_113 VGND VGND VPWR VPWR sky130_fd_sc_hd__decap_3
XTAP_TAPCELL_ROW_91_1346 VGND VPWR sky130_fd_sc_hd__tapvpwrvgnd_1
XFILLER_106_295 VGND VGND VPWR VPWR sky130_fd_sc_hd__decap_3
XFILLER_79_146 VGND VGND VPWR VPWR sky130_fd_sc_hd__decap_3
XFILLER_48_511 VGND VGND VPWR VPWR sky130_fd_sc_hd__decap_3
XFILLER_94_105 VGND VGND VPWR VPWR sky130_fd_sc_hd__decap_3
XFILLER_95_617 VGND VGND VPWR VPWR sky130_fd_sc_hd__decap_3
XFILLER_0_584 VGND VGND VPWR VPWR sky130_fd_sc_hd__decap_3
XFILLER_48_533 VGND VGND VPWR VPWR sky130_fd_sc_hd__decap_3
XFILLER_57_72 VGND VGND VPWR VPWR sky130_fd_sc_hd__decap_3
XFILLER_75_352 VGND VGND VPWR VPWR sky130_fd_sc_hd__decap_3
XFILLER_35_238 VGND VGND VPWR VPWR sky130_fd_sc_hd__fill_2
XFILLER_75_396 VGND VGND VPWR VPWR sky130_fd_sc_hd__decap_3
XFILLER_16_441 VGND VGND VPWR VPWR sky130_fd_sc_hd__decap_3
XFILLER_63_569 VGND VGND VPWR VPWR sky130_fd_sc_hd__decap_3
XTAP_TAPCELL_ROW_18_469 VGND VPWR sky130_fd_sc_hd__tapvpwrvgnd_1
XFILLER_71_591 VGND VGND VPWR VPWR sky130_fd_sc_hd__decap_3
XFILLER_73_93 VGND VGND VPWR VPWR sky130_fd_sc_hd__decap_3
XFILLER_92_6 VGND VGND VPWR VPWR sky130_fd_sc_hd__decap_3
XTAP_TAPCELL_ROW_100_1453 VGND VPWR sky130_fd_sc_hd__tapvpwrvgnd_1
XFILLER_31_499 VGND VGND VPWR VPWR sky130_fd_sc_hd__fill_1
XFILLER_8_673 VGND VGND VPWR VPWR sky130_fd_sc_hd__decap_3
X_4510_ _7324_/Q _7292_/Q _4517_/S VGND VGND VPWR VPWR _7324_/D sky130_fd_sc_hd__mux2_2
XFILLER_7_161 VGND VGND VPWR VPWR sky130_fd_sc_hd__decap_3
X_4441_ _4813_/B _4441_/B VGND VGND VPWR VPWR _4827_/A sky130_fd_sc_hd__nand2_2
X_7160_ clkload6/A _7160_/D _6440_/Y VGND VGND VPWR VPWR _7160_/Q sky130_fd_sc_hd__dfrtp_2
XPHY_EDGE_ROW_9_Right_9 VGND VGND VPWR VPWR sky130_fd_sc_hd__decap_3
X_4372_ _4372_/A _4627_/A VGND VGND VPWR VPWR _5018_/A sky130_fd_sc_hd__or2_2
XFILLER_112_221 VGND VGND VPWR VPWR sky130_fd_sc_hd__fill_1
XFILLER_112_243 VGND VGND VPWR VPWR sky130_fd_sc_hd__fill_1
XFILLER_86_606 VGND VGND VPWR VPWR sky130_fd_sc_hd__fill_1
X_7091_ clkload7/A _7091_/D _6371_/Y VGND VGND VPWR VPWR _7091_/Q sky130_fd_sc_hd__dfrtp_2
X_3323_ _5129_/A _3519_/B _5294_/A _3403_/A VGND VGND VPWR VPWR _3323_/X sky130_fd_sc_hd__a31o_2
XFILLER_112_276 VGND VGND VPWR VPWR sky130_fd_sc_hd__decap_3
XFILLER_39_500 VGND VGND VPWR VPWR sky130_fd_sc_hd__decap_3
XFILLER_85_116 VGND VGND VPWR VPWR sky130_fd_sc_hd__decap_3
XTAP_TAPCELL_ROW_111_1582 VGND VPWR sky130_fd_sc_hd__tapvpwrvgnd_1
XPHY_EDGE_ROW_107_Right_107 VGND VGND VPWR VPWR sky130_fd_sc_hd__decap_3
XFILLER_98_488 VGND VGND VPWR VPWR sky130_fd_sc_hd__decap_3
XFILLER_79_691 VGND VGND VPWR VPWR sky130_fd_sc_hd__fill_1
XFILLER_85_149 VGND VGND VPWR VPWR sky130_fd_sc_hd__decap_3
XFILLER_94_672 VGND VGND VPWR VPWR sky130_fd_sc_hd__decap_3
XFILLER_54_525 VGND VGND VPWR VPWR sky130_fd_sc_hd__decap_3
XFILLER_66_396 VGND VGND VPWR VPWR sky130_fd_sc_hd__decap_3
XFILLER_93_182 VGND VGND VPWR VPWR sky130_fd_sc_hd__decap_3
XTAP_TAPCELL_ROW_37_701 VGND VPWR sky130_fd_sc_hd__tapvpwrvgnd_1
XFILLER_54_569 VGND VGND VPWR VPWR sky130_fd_sc_hd__decap_3
XFILLER_81_355 VGND VGND VPWR VPWR sky130_fd_sc_hd__decap_3
X_6944_ _6959_/CLK _6944_/D VGND VGND VPWR VPWR _6944_/Q sky130_fd_sc_hd__dfxtp_2
XFILLER_81_388 VGND VGND VPWR VPWR sky130_fd_sc_hd__decap_3
XFILLER_81_399 VGND VGND VPWR VPWR sky130_fd_sc_hd__decap_3
XFILLER_22_433 VGND VGND VPWR VPWR sky130_fd_sc_hd__fill_1
XFILLER_34_271 VGND VGND VPWR VPWR sky130_fd_sc_hd__decap_3
X_6875_ _7392_/CLK _6875_/D VGND VGND VPWR VPWR _6875_/Q sky130_fd_sc_hd__dfxtp_2
XFILLER_22_455 VGND VGND VPWR VPWR sky130_fd_sc_hd__decap_3
XFILLER_22_477 VGND VGND VPWR VPWR sky130_fd_sc_hd__decap_3
X_4708_ _7001_/Q _4825_/B VGND VGND VPWR VPWR _4826_/A sky130_fd_sc_hd__and2_2
XFILLER_108_527 VGND VGND VPWR VPWR sky130_fd_sc_hd__decap_3
X_5688_ _7350_/Q hold935/X _5708_/S VGND VGND VPWR VPWR _5688_/X sky130_fd_sc_hd__mux2_2
X_4639_ _4639_/A _4948_/B VGND VGND VPWR VPWR _4918_/A sky130_fd_sc_hd__or2_2
XFILLER_78_38 VGND VGND VPWR VPWR sky130_fd_sc_hd__decap_3
XFILLER_89_411 VGND VGND VPWR VPWR sky130_fd_sc_hd__decap_3
X_7358_ _7358_/CLK _7358_/D _6638_/Y VGND VGND VPWR VPWR _7358_/Q sky130_fd_sc_hd__dfrtp_2
Xhold640 _6889_/Q VGND VGND VPWR VPWR _6889_/D sky130_fd_sc_hd__dlygate4sd3_1
Xhold651 _6865_/Q VGND VGND VPWR VPWR _6865_/D sky130_fd_sc_hd__dlygate4sd3_1
Xhold662 _6832_/Q VGND VGND VPWR VPWR _6832_/D sky130_fd_sc_hd__dlygate4sd3_1
XFILLER_77_606 VGND VGND VPWR VPWR sky130_fd_sc_hd__decap_3
X_7289_ _7356_/CLK _7289_/D _6569_/Y VGND VGND VPWR VPWR _7289_/Q sky130_fd_sc_hd__dfrtp_2
Xhold673 _6825_/Q VGND VGND VPWR VPWR _6825_/D sky130_fd_sc_hd__dlygate4sd3_1
Xhold684 _6756_/Q VGND VGND VPWR VPWR _6756_/D sky130_fd_sc_hd__dlygate4sd3_1
Xhold695 _6742_/Q VGND VGND VPWR VPWR _6742_/D sky130_fd_sc_hd__dlygate4sd3_1
X_6309_ _6672_/A VGND VGND VPWR VPWR _6309_/Y sky130_fd_sc_hd__inv_2
XFILLER_103_254 VGND VGND VPWR VPWR sky130_fd_sc_hd__decap_3
XFILLER_76_138 VGND VGND VPWR VPWR sky130_fd_sc_hd__fill_2
XFILLER_94_15 VGND VGND VPWR VPWR sky130_fd_sc_hd__decap_3
XFILLER_57_330 VGND VGND VPWR VPWR sky130_fd_sc_hd__decap_3
XFILLER_57_352 VGND VGND VPWR VPWR sky130_fd_sc_hd__decap_3
XFILLER_85_661 VGND VGND VPWR VPWR sky130_fd_sc_hd__decap_3
XFILLER_94_48 VGND VGND VPWR VPWR sky130_fd_sc_hd__fill_2
XFILLER_17_216 VGND VGND VPWR VPWR sky130_fd_sc_hd__decap_3
XFILLER_27_31 VGND VGND VPWR VPWR sky130_fd_sc_hd__decap_3
XFILLER_57_374 VGND VGND VPWR VPWR sky130_fd_sc_hd__fill_2
XFILLER_84_182 VGND VGND VPWR VPWR sky130_fd_sc_hd__decap_3
XFILLER_91_119 VGND VGND VPWR VPWR sky130_fd_sc_hd__fill_2
XFILLER_17_249 VGND VGND VPWR VPWR sky130_fd_sc_hd__decap_3
XFILLER_27_64 VGND VGND VPWR VPWR sky130_fd_sc_hd__decap_3
XFILLER_60_528 VGND VGND VPWR VPWR sky130_fd_sc_hd__decap_3
XFILLER_72_377 VGND VGND VPWR VPWR sky130_fd_sc_hd__fill_1
XFILLER_72_388 VGND VGND VPWR VPWR sky130_fd_sc_hd__decap_3
XTAP_TAPCELL_ROW_15_428 VGND VPWR sky130_fd_sc_hd__tapvpwrvgnd_1
XFILLER_13_455 VGND VGND VPWR VPWR sky130_fd_sc_hd__decap_3
XFILLER_40_241 VGND VGND VPWR VPWR sky130_fd_sc_hd__fill_1
XFILLER_43_63 VGND VGND VPWR VPWR sky130_fd_sc_hd__decap_3
XFILLER_43_96 VGND VGND VPWR VPWR sky130_fd_sc_hd__decap_3
XFILLER_5_643 VGND VGND VPWR VPWR sky130_fd_sc_hd__decap_3
XFILLER_4_153 VGND VGND VPWR VPWR sky130_fd_sc_hd__decap_3
XFILLER_4_24 VGND VGND VPWR VPWR sky130_fd_sc_hd__decap_3
XFILLER_5_676 VGND VGND VPWR VPWR sky130_fd_sc_hd__decap_3
XFILLER_4_197 VGND VGND VPWR VPWR sky130_fd_sc_hd__decap_3
XFILLER_4_35 VGND VGND VPWR VPWR sky130_fd_sc_hd__decap_3
XFILLER_4_68 VGND VGND VPWR VPWR sky130_fd_sc_hd__decap_3
XFILLER_67_105 VGND VGND VPWR VPWR sky130_fd_sc_hd__decap_3
XFILLER_68_60 VGND VGND VPWR VPWR sky130_fd_sc_hd__decap_3
XFILLER_68_628 VGND VGND VPWR VPWR sky130_fd_sc_hd__decap_3
XFILLER_67_116 VGND VGND VPWR VPWR sky130_fd_sc_hd__fill_2
XFILLER_95_425 VGND VGND VPWR VPWR sky130_fd_sc_hd__decap_3
XFILLER_63_322 VGND VGND VPWR VPWR sky130_fd_sc_hd__fill_1
XFILLER_75_160 VGND VGND VPWR VPWR sky130_fd_sc_hd__decap_3
XFILLER_76_672 VGND VGND VPWR VPWR sky130_fd_sc_hd__decap_3
XFILLER_36_558 VGND VGND VPWR VPWR sky130_fd_sc_hd__decap_3
XFILLER_63_333 VGND VGND VPWR VPWR sky130_fd_sc_hd__decap_3
XFILLER_63_355 VGND VGND VPWR VPWR sky130_fd_sc_hd__decap_3
XFILLER_91_664 VGND VGND VPWR VPWR sky130_fd_sc_hd__decap_3
Xplace322 _3358_/X VGND VGND VPWR VPWR _4356_/A2 sky130_fd_sc_hd__buf_2
Xplace311 _4577_/B VGND VGND VPWR VPWR _4561_/B sky130_fd_sc_hd__buf_2
Xplace300 _3634_/Y VGND VGND VPWR VPWR _3991_/B sky130_fd_sc_hd__buf_4
XFILLER_23_208 VGND VGND VPWR VPWR sky130_fd_sc_hd__fill_2
XFILLER_23_219 VGND VGND VPWR VPWR sky130_fd_sc_hd__decap_3
XFILLER_63_388 VGND VGND VPWR VPWR sky130_fd_sc_hd__decap_3
Xplace355 _5080_/S VGND VGND VPWR VPWR _4879_/S sky130_fd_sc_hd__buf_2
Xplace344 _4394_/B VGND VGND VPWR VPWR _4435_/B1 sky130_fd_sc_hd__buf_2
Xplace333 _3591_/A VGND VGND VPWR VPWR _4376_/A sky130_fd_sc_hd__buf_2
X_4990_ _4620_/A _4989_/X _4374_/X VGND VGND VPWR VPWR _5004_/B sky130_fd_sc_hd__o21ai_2
XFILLER_16_282 VGND VGND VPWR VPWR sky130_fd_sc_hd__decap_3
XFILLER_63_399 VGND VGND VPWR VPWR sky130_fd_sc_hd__decap_3
Xplace388 _4672_/B VGND VGND VPWR VPWR _5605_/B sky130_fd_sc_hd__buf_2
Xplace377 _3442_/A VGND VGND VPWR VPWR _3709_/B1 sky130_fd_sc_hd__buf_2
Xplace366 _4248_/A VGND VGND VPWR VPWR _3556_/A sky130_fd_sc_hd__buf_2
X_3941_ _7369_/Q _4484_/A0 _3945_/S VGND VGND VPWR VPWR _7369_/D sky130_fd_sc_hd__mux2_2
XFILLER_31_241 VGND VGND VPWR VPWR sky130_fd_sc_hd__decap_3
Xplace399 _4499_/S VGND VGND VPWR VPWR _4488_/S sky130_fd_sc_hd__buf_2
X_6660_ _6660_/A VGND VGND VPWR VPWR _6660_/Y sky130_fd_sc_hd__inv_2
X_3872_ _6921_/Q _3906_/A2 _3906_/B1 _6695_/Q _3871_/X VGND VGND VPWR VPWR _3872_/X
+ sky130_fd_sc_hd__a221o_2
X_6591_ _6634_/A VGND VGND VPWR VPWR _6591_/Y sky130_fd_sc_hd__inv_2
X_5611_ _5611_/A _5634_/B VGND VGND VPWR VPWR _7022_/D sky130_fd_sc_hd__and2_2
XFILLER_31_296 VGND VGND VPWR VPWR sky130_fd_sc_hd__decap_3
XFILLER_105_508 VGND VGND VPWR VPWR sky130_fd_sc_hd__decap_3
X_7212_ _7374_/CLK _7212_/D _6492_/Y VGND VGND VPWR VPWR _7212_/Q sky130_fd_sc_hd__dfrtp_2
X_4424_ _4425_/A _4425_/C _4649_/B VGND VGND VPWR VPWR _4446_/A sky130_fd_sc_hd__a21oi_2
XTAP_TAPCELL_ROW_113_1611 VGND VPWR sky130_fd_sc_hd__tapvpwrvgnd_1
X_7143_ _7369_/CLK _7143_/D _6423_/Y VGND VGND VPWR VPWR _7143_/Q sky130_fd_sc_hd__dfrtp_2
X_4355_ _4355_/A _4355_/B VGND VGND VPWR VPWR _4355_/X sky130_fd_sc_hd__or2_2
XPHY_EDGE_ROW_92_Left_209 VGND VGND VPWR VPWR sky130_fd_sc_hd__decap_3
XFILLER_113_552 VGND VGND VPWR VPWR sky130_fd_sc_hd__decap_3
XFILLER_48_19 VGND VGND VPWR VPWR sky130_fd_sc_hd__decap_3
XFILLER_59_617 VGND VGND VPWR VPWR sky130_fd_sc_hd__decap_3
X_7074_ _7266_/CLK _7074_/D _6354_/Y VGND VGND VPWR VPWR _7074_/Q sky130_fd_sc_hd__dfrtp_2
X_3306_ _5129_/A _3328_/A _6981_/D _4696_/B _3340_/B VGND VGND VPWR VPWR _3378_/A
+ sky130_fd_sc_hd__o221a_2
XFILLER_100_224 VGND VGND VPWR VPWR sky130_fd_sc_hd__fill_1
XFILLER_113_585 VGND VGND VPWR VPWR sky130_fd_sc_hd__decap_3
XFILLER_58_116 VGND VGND VPWR VPWR sky130_fd_sc_hd__decap_3
X_4286_ _4286_/A _4286_/B VGND VGND VPWR VPWR _4288_/C sky130_fd_sc_hd__or2_2
XFILLER_100_246 VGND VGND VPWR VPWR sky130_fd_sc_hd__decap_3
XFILLER_67_661 VGND VGND VPWR VPWR sky130_fd_sc_hd__decap_3
XFILLER_104_47 VGND VGND VPWR VPWR sky130_fd_sc_hd__decap_3
XFILLER_104_69 VGND VGND VPWR VPWR sky130_fd_sc_hd__decap_3
XFILLER_27_514 VGND VGND VPWR VPWR sky130_fd_sc_hd__decap_3
XFILLER_64_18 VGND VGND VPWR VPWR sky130_fd_sc_hd__decap_3
XFILLER_73_119 VGND VGND VPWR VPWR sky130_fd_sc_hd__fill_1
XFILLER_39_396 VGND VGND VPWR VPWR sky130_fd_sc_hd__decap_3
XFILLER_54_355 VGND VGND VPWR VPWR sky130_fd_sc_hd__decap_3
XFILLER_64_29 VGND VGND VPWR VPWR sky130_fd_sc_hd__decap_3
XFILLER_82_642 VGND VGND VPWR VPWR sky130_fd_sc_hd__fill_2
XFILLER_42_517 VGND VGND VPWR VPWR sky130_fd_sc_hd__fill_1
XFILLER_82_675 VGND VGND VPWR VPWR sky130_fd_sc_hd__decap_3
XFILLER_35_580 VGND VGND VPWR VPWR sky130_fd_sc_hd__decap_3
X_6927_ _6931_/CLK _6927_/D VGND VGND VPWR VPWR _6927_/Q sky130_fd_sc_hd__dfxtp_2
XFILLER_80_17 VGND VGND VPWR VPWR sky130_fd_sc_hd__decap_3
Xfanout23 _6570_/A VGND VGND VPWR VPWR _6532_/A sky130_fd_sc_hd__buf_2
Xfanout34 fanout38/X VGND VGND VPWR VPWR _6637_/A sky130_fd_sc_hd__buf_2
Xfanout45 _6643_/A VGND VGND VPWR VPWR _6611_/A sky130_fd_sc_hd__buf_2
Xfanout56 _6685_/A VGND VGND VPWR VPWR _6684_/A sky130_fd_sc_hd__buf_2
X_6858_ _6911_/CLK _6858_/D VGND VGND VPWR VPWR _6858_/Q sky130_fd_sc_hd__dfxtp_2
XFILLER_10_414 VGND VGND VPWR VPWR sky130_fd_sc_hd__decap_3
XFILLER_13_11 VGND VGND VPWR VPWR sky130_fd_sc_hd__decap_3
Xfanout67 _6619_/A VGND VGND VPWR VPWR _6558_/A sky130_fd_sc_hd__clkdlybuf4s25_1
XTAP_TAPCELL_ROW_40_729 VGND VPWR sky130_fd_sc_hd__tapvpwrvgnd_1
XFILLER_13_44 VGND VGND VPWR VPWR sky130_fd_sc_hd__decap_3
XFILLER_13_66 VGND VGND VPWR VPWR sky130_fd_sc_hd__decap_3
XFILLER_22_296 VGND VGND VPWR VPWR sky130_fd_sc_hd__decap_3
X_6789_ _6975_/CLK _6789_/D VGND VGND VPWR VPWR _6789_/Q sky130_fd_sc_hd__dfxtp_2
XFILLER_6_418 VGND VGND VPWR VPWR sky130_fd_sc_hd__fill_2
XFILLER_108_346 VGND VGND VPWR VPWR sky130_fd_sc_hd__decap_3
XFILLER_89_26 VGND VGND VPWR VPWR sky130_fd_sc_hd__decap_3
XFILLER_89_48 VGND VGND VPWR VPWR sky130_fd_sc_hd__decap_3
XTAP_TAPCELL_ROW_20_497 VGND VPWR sky130_fd_sc_hd__tapvpwrvgnd_1
XTAP_TAPCELL_ROW_20_486 VGND VPWR sky130_fd_sc_hd__tapvpwrvgnd_1
XFILLER_2_624 VGND VGND VPWR VPWR sky130_fd_sc_hd__decap_3
XTAP_TAPCELL_ROW_75_1149 VGND VPWR sky130_fd_sc_hd__tapvpwrvgnd_1
XFILLER_104_541 VGND VGND VPWR VPWR sky130_fd_sc_hd__decap_3
XFILLER_1_134 VGND VGND VPWR VPWR sky130_fd_sc_hd__decap_3
XFILLER_2_657 VGND VGND VPWR VPWR sky130_fd_sc_hd__decap_3
XFILLER_89_252 VGND VGND VPWR VPWR sky130_fd_sc_hd__decap_3
XFILLER_49_138 VGND VGND VPWR VPWR sky130_fd_sc_hd__decap_3
XFILLER_89_285 VGND VGND VPWR VPWR sky130_fd_sc_hd__decap_3
XFILLER_77_458 VGND VGND VPWR VPWR sky130_fd_sc_hd__decap_3
XFILLER_38_85 VGND VGND VPWR VPWR sky130_fd_sc_hd__decap_3
XFILLER_45_311 VGND VGND VPWR VPWR sky130_fd_sc_hd__decap_3
XFILLER_58_672 VGND VGND VPWR VPWR sky130_fd_sc_hd__decap_3
XFILLER_73_620 VGND VGND VPWR VPWR sky130_fd_sc_hd__decap_3
XFILLER_92_417 VGND VGND VPWR VPWR sky130_fd_sc_hd__decap_3
Xhold1170 _7149_/Q VGND VGND VPWR VPWR _5367_/A0 sky130_fd_sc_hd__dlygate4sd3_1
XTAP_TAPCELL_ROW_48_829 VGND VPWR sky130_fd_sc_hd__tapvpwrvgnd_1
XFILLER_72_130 VGND VGND VPWR VPWR sky130_fd_sc_hd__fill_1
XFILLER_85_491 VGND VGND VPWR VPWR sky130_fd_sc_hd__decap_3
Xhold1181 _7295_/Q VGND VGND VPWR VPWR _4571_/A sky130_fd_sc_hd__dlygate4sd3_1
Xhold1192 _7292_/Q VGND VGND VPWR VPWR _4577_/A sky130_fd_sc_hd__dlygate4sd3_1
XFILLER_72_141 VGND VGND VPWR VPWR sky130_fd_sc_hd__decap_3
XTAP_TAPCELL_ROW_86_1289 VGND VPWR sky130_fd_sc_hd__tapvpwrvgnd_1
XTAP_TAPCELL_ROW_86_1278 VGND VPWR sky130_fd_sc_hd__tapvpwrvgnd_1
XFILLER_54_62 VGND VGND VPWR VPWR sky130_fd_sc_hd__decap_3
XFILLER_72_185 VGND VGND VPWR VPWR sky130_fd_sc_hd__decap_3
XTAP_TAPCELL_ROW_28_586 VGND VPWR sky130_fd_sc_hd__tapvpwrvgnd_1
XFILLER_13_252 VGND VGND VPWR VPWR sky130_fd_sc_hd__decap_3
XFILLER_41_550 VGND VGND VPWR VPWR sky130_fd_sc_hd__fill_1
XFILLER_41_561 VGND VGND VPWR VPWR sky130_fd_sc_hd__decap_3
XFILLER_9_234 VGND VGND VPWR VPWR sky130_fd_sc_hd__fill_2
XFILLER_13_296 VGND VGND VPWR VPWR sky130_fd_sc_hd__fill_2
Xclkload15 _6978_/CLK VGND VGND VPWR VPWR clkload15/X sky130_fd_sc_hd__clkbuf_1
Xclkload26 _7266_/CLK VGND VGND VPWR VPWR clkload26/X sky130_fd_sc_hd__clkbuf_8
XFILLER_9_278 VGND VGND VPWR VPWR sky130_fd_sc_hd__fill_2
Xclkload37 _7374_/CLK VGND VGND VPWR VPWR clkload37/X sky130_fd_sc_hd__clkbuf_8
XFILLER_55_6 VGND VGND VPWR VPWR sky130_fd_sc_hd__decap_3
XFILLER_79_81 VGND VGND VPWR VPWR sky130_fd_sc_hd__decap_3
X_4140_ _4117_/Y _4124_/B _4890_/B _4886_/A VGND VGND VPWR VPWR _4140_/X sky130_fd_sc_hd__a2bb2o_2
XFILLER_110_533 VGND VGND VPWR VPWR sky130_fd_sc_hd__decap_3
XFILLER_49_650 VGND VGND VPWR VPWR sky130_fd_sc_hd__decap_3
XFILLER_56_609 VGND VGND VPWR VPWR sky130_fd_sc_hd__decap_3
XFILLER_68_458 VGND VGND VPWR VPWR sky130_fd_sc_hd__decap_3
X_4071_ _7307_/Q _4488_/S _4437_/B1 _7371_/Q _4429_/C1 VGND VGND VPWR VPWR _4071_/X
+ sky130_fd_sc_hd__a221o_2
XFILLER_110_577 VGND VGND VPWR VPWR sky130_fd_sc_hd__decap_3
XFILLER_48_171 VGND VGND VPWR VPWR sky130_fd_sc_hd__decap_3
XFILLER_95_299 VGND VGND VPWR VPWR sky130_fd_sc_hd__decap_3
XFILLER_63_130 VGND VGND VPWR VPWR sky130_fd_sc_hd__fill_1
XFILLER_64_631 VGND VGND VPWR VPWR sky130_fd_sc_hd__decap_3
XFILLER_76_491 VGND VGND VPWR VPWR sky130_fd_sc_hd__decap_3
XFILLER_64_675 VGND VGND VPWR VPWR sky130_fd_sc_hd__decap_3
X_4973_ _5595_/B _4973_/B _3813_/Y VGND VGND VPWR VPWR _4973_/X sky130_fd_sc_hd__or3b_2
XFILLER_32_550 VGND VGND VPWR VPWR sky130_fd_sc_hd__decap_3
X_6712_ _7401_/CLK _6712_/D VGND VGND VPWR VPWR _6712_/Q sky130_fd_sc_hd__dfxtp_2
X_3924_ hold992/X _5151_/A _3923_/X VGND VGND VPWR VPWR _7376_/D sky130_fd_sc_hd__o21a_2
X_6643_ _6643_/A VGND VGND VPWR VPWR _6643_/Y sky130_fd_sc_hd__inv_2
Xclkload9 clkload9/A VGND VGND VPWR VPWR clkload9/X sky130_fd_sc_hd__clkbuf_8
X_3855_ _3728_/Y _3847_/X _3849_/X _3714_/X _3854_/X VGND VGND VPWR VPWR _3855_/X
+ sky130_fd_sc_hd__a221o_2
X_6574_ _6604_/A VGND VGND VPWR VPWR _6574_/Y sky130_fd_sc_hd__inv_2
X_3786_ _6751_/Q _3661_/X _3656_/Y _6733_/Q VGND VGND VPWR VPWR _3786_/X sky130_fd_sc_hd__a22o_2
XFILLER_105_327 VGND VGND VPWR VPWR sky130_fd_sc_hd__fill_2
Xoutput520 _7009_/Q VGND VGND VPWR VPWR pc_out[0] sky130_fd_sc_hd__clkdlybuf4s25_1
XFILLER_59_29 VGND VGND VPWR VPWR sky130_fd_sc_hd__fill_1
Xoutput542 _6979_/Q VGND VGND VPWR VPWR pc_out[2] sky130_fd_sc_hd__clkdlybuf4s25_1
Xoutput531 _7010_/Q VGND VGND VPWR VPWR pc_out[1] sky130_fd_sc_hd__clkdlybuf4s25_1
X_4407_ _7370_/Q _4435_/B1 _4436_/B1 _7178_/Q _4406_/X VGND VGND VPWR VPWR _4407_/X
+ sky130_fd_sc_hd__a221o_2
XFILLER_99_572 VGND VGND VPWR VPWR sky130_fd_sc_hd__decap_3
XFILLER_99_561 VGND VGND VPWR VPWR sky130_fd_sc_hd__fill_2
XFILLER_101_511 VGND VGND VPWR VPWR sky130_fd_sc_hd__decap_3
XFILLER_113_382 VGND VGND VPWR VPWR sky130_fd_sc_hd__decap_3
XFILLER_115_35 VGND VGND VPWR VPWR sky130_fd_sc_hd__decap_3
XFILLER_59_436 VGND VGND VPWR VPWR sky130_fd_sc_hd__decap_3
XFILLER_86_211 VGND VGND VPWR VPWR sky130_fd_sc_hd__decap_3
X_7126_ clkload7/A _7126_/D _6406_/Y VGND VGND VPWR VPWR _7126_/Q sky130_fd_sc_hd__dfrtp_2
X_4338_ _7319_/Q _3979_/S _4338_/B1 _7351_/Q _3556_/A VGND VGND VPWR VPWR _4338_/X
+ sky130_fd_sc_hd__a221o_2
XFILLER_101_544 VGND VGND VPWR VPWR sky130_fd_sc_hd__fill_1
XFILLER_115_57 VGND VGND VPWR VPWR sky130_fd_sc_hd__decap_3
XFILLER_59_469 VGND VGND VPWR VPWR sky130_fd_sc_hd__fill_1
XFILLER_75_28 VGND VGND VPWR VPWR sky130_fd_sc_hd__decap_3
X_7057_ clkload8/A _7057_/D _6337_/Y VGND VGND VPWR VPWR _7057_/Q sky130_fd_sc_hd__dfrtp_2
X_4269_ _7230_/Q _4469_/A3 _4503_/S _7043_/Q _4268_/X VGND VGND VPWR VPWR _4271_/C
+ sky130_fd_sc_hd__a221o_2
XFILLER_101_577 VGND VGND VPWR VPWR sky130_fd_sc_hd__decap_3
XFILLER_55_620 VGND VGND VPWR VPWR sky130_fd_sc_hd__decap_3
XFILLER_27_333 VGND VGND VPWR VPWR sky130_fd_sc_hd__decap_3
XFILLER_27_344 VGND VGND VPWR VPWR sky130_fd_sc_hd__decap_3
XFILLER_54_130 VGND VGND VPWR VPWR sky130_fd_sc_hd__decap_3
XFILLER_55_653 VGND VGND VPWR VPWR sky130_fd_sc_hd__decap_3
XFILLER_42_303 VGND VGND VPWR VPWR sky130_fd_sc_hd__fill_2
XFILLER_54_141 VGND VGND VPWR VPWR sky130_fd_sc_hd__decap_3
XFILLER_27_399 VGND VGND VPWR VPWR sky130_fd_sc_hd__decap_3
XFILLER_54_174 VGND VGND VPWR VPWR sky130_fd_sc_hd__decap_3
XFILLER_82_483 VGND VGND VPWR VPWR sky130_fd_sc_hd__decap_3
XFILLER_91_38 VGND VGND VPWR VPWR sky130_fd_sc_hd__decap_3
XFILLER_24_32 VGND VGND VPWR VPWR sky130_fd_sc_hd__decap_3
XFILLER_42_347 VGND VGND VPWR VPWR sky130_fd_sc_hd__decap_3
XTAP_TAPCELL_ROW_25_556 VGND VPWR sky130_fd_sc_hd__tapvpwrvgnd_1
XFILLER_24_54 VGND VGND VPWR VPWR sky130_fd_sc_hd__fill_1
XTAP_TAPCELL_ROW_53_887 VGND VPWR sky130_fd_sc_hd__tapvpwrvgnd_1
XFILLER_10_222 VGND VGND VPWR VPWR sky130_fd_sc_hd__decap_3
XFILLER_50_380 VGND VGND VPWR VPWR sky130_fd_sc_hd__decap_3
XFILLER_109_644 VGND VGND VPWR VPWR sky130_fd_sc_hd__decap_3
XFILLER_109_688 VGND VGND VPWR VPWR sky130_fd_sc_hd__decap_3
XFILLER_40_75 VGND VGND VPWR VPWR sky130_fd_sc_hd__fill_1
XFILLER_2_410 VGND VGND VPWR VPWR sky130_fd_sc_hd__decap_3
XFILLER_2_421 VGND VGND VPWR VPWR sky130_fd_sc_hd__decap_3
XFILLER_2_454 VGND VGND VPWR VPWR sky130_fd_sc_hd__decap_3
XFILLER_49_40 VGND VGND VPWR VPWR sky130_fd_sc_hd__decap_3
XFILLER_1_14 VGND VGND VPWR VPWR sky130_fd_sc_hd__decap_3
XFILLER_38_609 VGND VGND VPWR VPWR sky130_fd_sc_hd__decap_3
XFILLER_1_47 VGND VGND VPWR VPWR sky130_fd_sc_hd__decap_3
XFILLER_65_428 VGND VGND VPWR VPWR sky130_fd_sc_hd__decap_3
XFILLER_92_203 VGND VGND VPWR VPWR sky130_fd_sc_hd__decap_3
XTAP_TAPCELL_ROW_88_1307 VGND VPWR sky130_fd_sc_hd__tapvpwrvgnd_1
XFILLER_105_90 VGND VGND VPWR VPWR sky130_fd_sc_hd__decap_3
XFILLER_18_333 VGND VGND VPWR VPWR sky130_fd_sc_hd__decap_3
XFILLER_1_69 VGND VGND VPWR VPWR sky130_fd_sc_hd__decap_3
XFILLER_46_642 VGND VGND VPWR VPWR sky130_fd_sc_hd__fill_2
XFILLER_45_141 VGND VGND VPWR VPWR sky130_fd_sc_hd__decap_3
XFILLER_46_675 VGND VGND VPWR VPWR sky130_fd_sc_hd__decap_3
XFILLER_65_83 VGND VGND VPWR VPWR sky130_fd_sc_hd__decap_3
XFILLER_73_461 VGND VGND VPWR VPWR sky130_fd_sc_hd__decap_3
XFILLER_61_623 VGND VGND VPWR VPWR sky130_fd_sc_hd__decap_3
XFILLER_61_656 VGND VGND VPWR VPWR sky130_fd_sc_hd__decap_3
XFILLER_14_583 VGND VGND VPWR VPWR sky130_fd_sc_hd__decap_3
XFILLER_81_60 VGND VGND VPWR VPWR sky130_fd_sc_hd__decap_3
XFILLER_81_93 VGND VGND VPWR VPWR sky130_fd_sc_hd__decap_3
XTAP_TAPCELL_ROW_99_1436 VGND VPWR sky130_fd_sc_hd__tapvpwrvgnd_1
X_3640_ _3635_/X _3637_/X _3639_/X VGND VGND VPWR VPWR _3640_/X sky130_fd_sc_hd__o21ba_2
X_3571_ _3326_/A _3424_/S _5648_/B _3569_/X _3570_/X VGND VGND VPWR VPWR _3607_/B
+ sky130_fd_sc_hd__o32a_2
XFILLER_115_603 VGND VGND VPWR VPWR sky130_fd_sc_hd__decap_3
XFILLER_53_3 VGND VGND VPWR VPWR sky130_fd_sc_hd__decap_3
X_6290_ _6388_/A VGND VGND VPWR VPWR _6290_/Y sky130_fd_sc_hd__inv_2
X_5310_ _5310_/A0 _4836_/X _5323_/S VGND VGND VPWR VPWR _7175_/D sky130_fd_sc_hd__mux2_2
XFILLER_114_124 VGND VGND VPWR VPWR sky130_fd_sc_hd__decap_3
XFILLER_115_647 VGND VGND VPWR VPWR sky130_fd_sc_hd__decap_3
XFILLER_5_281 VGND VGND VPWR VPWR sky130_fd_sc_hd__decap_3
XFILLER_114_168 VGND VGND VPWR VPWR sky130_fd_sc_hd__decap_3
X_5241_ _5241_/A0 _4806_/X _5245_/S VGND VGND VPWR VPWR _7209_/D sky130_fd_sc_hd__mux2_2
XFILLER_68_200 VGND VGND VPWR VPWR sky130_fd_sc_hd__decap_3
XFILLER_68_222 VGND VGND VPWR VPWR sky130_fd_sc_hd__decap_3
XFILLER_96_531 VGND VGND VPWR VPWR sky130_fd_sc_hd__fill_1
XFILLER_96_564 VGND VGND VPWR VPWR sky130_fd_sc_hd__decap_3
X_4123_ _4119_/X _4122_/X _4327_/A VGND VGND VPWR VPWR _4124_/B sky130_fd_sc_hd__o21a_2
X_4054_ _4054_/A _4456_/A VGND VGND VPWR VPWR _4658_/A sky130_fd_sc_hd__nand2_2
XFILLER_37_620 VGND VGND VPWR VPWR sky130_fd_sc_hd__fill_2
XFILLER_83_225 VGND VGND VPWR VPWR sky130_fd_sc_hd__fill_1
XFILLER_83_247 VGND VGND VPWR VPWR sky130_fd_sc_hd__decap_3
XFILLER_52_601 VGND VGND VPWR VPWR sky130_fd_sc_hd__decap_3
XFILLER_64_450 VGND VGND VPWR VPWR sky130_fd_sc_hd__fill_2
XTAP_TAPCELL_ROW_108_1543 VGND VPWR sky130_fd_sc_hd__tapvpwrvgnd_1
XFILLER_36_163 VGND VGND VPWR VPWR sky130_fd_sc_hd__decap_3
XFILLER_51_100 VGND VGND VPWR VPWR sky130_fd_sc_hd__decap_3
XFILLER_52_634 VGND VGND VPWR VPWR sky130_fd_sc_hd__decap_3
XFILLER_52_645 VGND VGND VPWR VPWR sky130_fd_sc_hd__decap_3
XFILLER_64_472 VGND VGND VPWR VPWR sky130_fd_sc_hd__decap_3
XFILLER_101_48 VGND VGND VPWR VPWR sky130_fd_sc_hd__decap_3
XFILLER_51_122 VGND VGND VPWR VPWR sky130_fd_sc_hd__decap_3
XFILLER_51_144 VGND VGND VPWR VPWR sky130_fd_sc_hd__decap_3
XFILLER_52_678 VGND VGND VPWR VPWR sky130_fd_sc_hd__decap_3
XFILLER_61_19 VGND VGND VPWR VPWR sky130_fd_sc_hd__decap_3
X_4956_ _4948_/Y _4951_/Y _4954_/X _4955_/X VGND VGND VPWR VPWR _5662_/C sky130_fd_sc_hd__a211o_2
XTAP_TAPCELL_ROW_22_515 VGND VPWR sky130_fd_sc_hd__tapvpwrvgnd_1
XFILLER_32_391 VGND VGND VPWR VPWR sky130_fd_sc_hd__fill_1
XFILLER_51_199 VGND VGND VPWR VPWR sky130_fd_sc_hd__decap_3
X_4887_ _4886_/A _4890_/B _4814_/A VGND VGND VPWR VPWR _4887_/Y sky130_fd_sc_hd__a21oi_2
X_3907_ _6781_/Q _3926_/B1 _3917_/B1 _6869_/Q _3906_/X VGND VGND VPWR VPWR _3907_/X
+ sky130_fd_sc_hd__a221o_2
XTAP_TAPCELL_ROW_50_857 VGND VPWR sky130_fd_sc_hd__tapvpwrvgnd_1
XTAP_TAPCELL_ROW_50_846 VGND VPWR sky130_fd_sc_hd__tapvpwrvgnd_1
XFILLER_20_553 VGND VGND VPWR VPWR sky130_fd_sc_hd__decap_3
X_6626_ _6664_/A VGND VGND VPWR VPWR _6626_/Y sky130_fd_sc_hd__inv_2
X_3838_ _6773_/Q _3886_/A2 _3886_/B1 _6761_/Q _3837_/X VGND VGND VPWR VPWR _3838_/X
+ sky130_fd_sc_hd__a221o_2
XFILLER_20_586 VGND VGND VPWR VPWR sky130_fd_sc_hd__fill_2
X_6557_ _6647_/A VGND VGND VPWR VPWR _6557_/Y sky130_fd_sc_hd__inv_2
XFILLER_106_625 VGND VGND VPWR VPWR sky130_fd_sc_hd__decap_3
XFILLER_10_12 VGND VGND VPWR VPWR sky130_fd_sc_hd__decap_3
X_3769_ _3746_/C _3767_/X _3768_/X _4799_/A VGND VGND VPWR VPWR _4944_/B sky130_fd_sc_hd__o31a_2
XFILLER_105_113 VGND VGND VPWR VPWR sky130_fd_sc_hd__decap_3
X_6488_ _6675_/A VGND VGND VPWR VPWR _6488_/Y sky130_fd_sc_hd__inv_2
XFILLER_106_669 VGND VGND VPWR VPWR sky130_fd_sc_hd__decap_3
XFILLER_10_56 VGND VGND VPWR VPWR sky130_fd_sc_hd__decap_3
XTAP_TAPCELL_ROW_72_1119 VGND VPWR sky130_fd_sc_hd__tapvpwrvgnd_1
XFILLER_105_179 VGND VGND VPWR VPWR sky130_fd_sc_hd__decap_3
XFILLER_59_211 VGND VGND VPWR VPWR sky130_fd_sc_hd__decap_3
XFILLER_86_27 VGND VGND VPWR VPWR sky130_fd_sc_hd__fill_1
XFILLER_113_190 VGND VGND VPWR VPWR sky130_fd_sc_hd__decap_3
XFILLER_59_255 VGND VGND VPWR VPWR sky130_fd_sc_hd__decap_3
XFILLER_86_49 VGND VGND VPWR VPWR sky130_fd_sc_hd__decap_3
XFILLER_87_564 VGND VGND VPWR VPWR sky130_fd_sc_hd__decap_3
X_7109_ _7363_/CLK _7109_/D _6389_/Y VGND VGND VPWR VPWR _7109_/Q sky130_fd_sc_hd__dfrtp_2
XFILLER_101_352 VGND VGND VPWR VPWR sky130_fd_sc_hd__fill_1
XFILLER_101_363 VGND VGND VPWR VPWR sky130_fd_sc_hd__decap_3
XFILLER_19_108 VGND VGND VPWR VPWR sky130_fd_sc_hd__decap_3
XFILLER_19_32 VGND VGND VPWR VPWR sky130_fd_sc_hd__decap_3
XFILLER_74_203 VGND VGND VPWR VPWR sky130_fd_sc_hd__fill_2
XFILLER_101_396 VGND VGND VPWR VPWR sky130_fd_sc_hd__decap_3
XFILLER_19_76 VGND VGND VPWR VPWR sky130_fd_sc_hd__decap_3
XFILLER_74_247 VGND VGND VPWR VPWR sky130_fd_sc_hd__decap_3
XTAP_TAPCELL_ROW_58_946 VGND VPWR sky130_fd_sc_hd__tapvpwrvgnd_1
XFILLER_27_141 VGND VGND VPWR VPWR sky130_fd_sc_hd__decap_3
XTAP_TAPCELL_ROW_2_273 VGND VPWR sky130_fd_sc_hd__tapvpwrvgnd_1
XFILLER_15_314 VGND VGND VPWR VPWR sky130_fd_sc_hd__decap_3
XFILLER_35_20 VGND VGND VPWR VPWR sky130_fd_sc_hd__decap_3
XFILLER_43_623 VGND VGND VPWR VPWR sky130_fd_sc_hd__decap_3
XFILLER_55_472 VGND VGND VPWR VPWR sky130_fd_sc_hd__decap_3
XFILLER_42_144 VGND VGND VPWR VPWR sky130_fd_sc_hd__decap_3
XFILLER_43_656 VGND VGND VPWR VPWR sky130_fd_sc_hd__decap_3
XFILLER_70_442 VGND VGND VPWR VPWR sky130_fd_sc_hd__decap_3
XTAP_TAPCELL_ROW_83_1248 VGND VPWR sky130_fd_sc_hd__tapvpwrvgnd_1
XFILLER_42_188 VGND VGND VPWR VPWR sky130_fd_sc_hd__decap_3
XFILLER_70_486 VGND VGND VPWR VPWR sky130_fd_sc_hd__decap_3
XFILLER_51_30 VGND VGND VPWR VPWR sky130_fd_sc_hd__decap_3
XFILLER_51_85 VGND VGND VPWR VPWR sky130_fd_sc_hd__decap_3
XFILLER_7_535 VGND VGND VPWR VPWR sky130_fd_sc_hd__decap_3
XFILLER_109_452 VGND VGND VPWR VPWR sky130_fd_sc_hd__decap_3
XTAP_TAPCELL_ROW_94_1377 VGND VPWR sky130_fd_sc_hd__tapvpwrvgnd_1
XFILLER_105_691 VGND VGND VPWR VPWR sky130_fd_sc_hd__fill_1
XFILLER_111_105 VGND VGND VPWR VPWR sky130_fd_sc_hd__decap_3
XFILLER_111_116 VGND VGND VPWR VPWR sky130_fd_sc_hd__decap_3
XFILLER_112_628 VGND VGND VPWR VPWR sky130_fd_sc_hd__decap_3
XFILLER_2_251 VGND VGND VPWR VPWR sky130_fd_sc_hd__fill_1
XFILLER_2_262 VGND VGND VPWR VPWR sky130_fd_sc_hd__decap_3
XFILLER_111_149 VGND VGND VPWR VPWR sky130_fd_sc_hd__fill_2
XFILLER_2_295 VGND VGND VPWR VPWR sky130_fd_sc_hd__decap_3
XFILLER_78_531 VGND VGND VPWR VPWR sky130_fd_sc_hd__fill_1
XFILLER_65_214 VGND VGND VPWR VPWR sky130_fd_sc_hd__decap_3
XFILLER_93_501 VGND VGND VPWR VPWR sky130_fd_sc_hd__decap_3
XFILLER_18_6 VGND VGND VPWR VPWR sky130_fd_sc_hd__decap_3
XFILLER_65_225 VGND VGND VPWR VPWR sky130_fd_sc_hd__decap_3
XFILLER_76_82 VGND VGND VPWR VPWR sky130_fd_sc_hd__fill_2
XFILLER_93_534 VGND VGND VPWR VPWR sky130_fd_sc_hd__decap_3
XFILLER_18_130 VGND VGND VPWR VPWR sky130_fd_sc_hd__decap_3
XFILLER_18_141 VGND VGND VPWR VPWR sky130_fd_sc_hd__decap_3
XFILLER_46_461 VGND VGND VPWR VPWR sky130_fd_sc_hd__decap_3
XFILLER_93_589 VGND VGND VPWR VPWR sky130_fd_sc_hd__decap_3
XFILLER_18_163 VGND VGND VPWR VPWR sky130_fd_sc_hd__decap_3
XFILLER_33_111 VGND VGND VPWR VPWR sky130_fd_sc_hd__fill_1
XFILLER_61_420 VGND VGND VPWR VPWR sky130_fd_sc_hd__decap_3
XFILLER_80_228 VGND VGND VPWR VPWR sky130_fd_sc_hd__decap_3
XFILLER_33_144 VGND VGND VPWR VPWR sky130_fd_sc_hd__decap_3
X_4810_ _4813_/A _4810_/B _4829_/B VGND VGND VPWR VPWR _4810_/X sky130_fd_sc_hd__or3_2
XFILLER_21_328 VGND VGND VPWR VPWR sky130_fd_sc_hd__decap_3
XFILLER_33_166 VGND VGND VPWR VPWR sky130_fd_sc_hd__fill_2
XFILLER_34_689 VGND VGND VPWR VPWR sky130_fd_sc_hd__decap_3
XFILLER_33_199 VGND VGND VPWR VPWR sky130_fd_sc_hd__decap_3
X_4741_ _4761_/B _4761_/C _4762_/B VGND VGND VPWR VPWR _4741_/X sky130_fd_sc_hd__a21o_2
XTAP_TAPCELL_ROW_103_1484 VGND VPWR sky130_fd_sc_hd__tapvpwrvgnd_1
X_4672_ _6991_/Q _4672_/B VGND VGND VPWR VPWR _4673_/B sky130_fd_sc_hd__nor2_2
X_6411_ _6535_/A VGND VGND VPWR VPWR _6411_/Y sky130_fd_sc_hd__inv_2
X_7391_ _7392_/CLK _7391_/D _6671_/Y VGND VGND VPWR VPWR _7391_/Q sky130_fd_sc_hd__dfrtp_2
X_6342_ _6347_/A VGND VGND VPWR VPWR _6342_/Y sky130_fd_sc_hd__inv_2
X_3554_ _7317_/Q _3979_/S _4338_/B1 _7349_/Q VGND VGND VPWR VPWR _3556_/B sky130_fd_sc_hd__a22o_2
XFILLER_88_306 VGND VGND VPWR VPWR sky130_fd_sc_hd__fill_2
X_6273_ _6523_/A VGND VGND VPWR VPWR _6273_/Y sky130_fd_sc_hd__inv_2
X_3485_ _3502_/A _3502_/B _3485_/C VGND VGND VPWR VPWR _5144_/A sky130_fd_sc_hd__or3_4
XFILLER_102_127 VGND VGND VPWR VPWR sky130_fd_sc_hd__fill_1
XFILLER_115_499 VGND VGND VPWR VPWR sky130_fd_sc_hd__decap_3
XFILLER_111_650 VGND VGND VPWR VPWR sky130_fd_sc_hd__decap_3
XFILLER_29_417 VGND VGND VPWR VPWR sky130_fd_sc_hd__decap_3
XFILLER_96_350 VGND VGND VPWR VPWR sky130_fd_sc_hd__decap_3
X_5155_ _4467_/B _3923_/X _5151_/X _5154_/Y VGND VGND VPWR VPWR _5155_/X sky130_fd_sc_hd__a31o_2
XFILLER_110_171 VGND VGND VPWR VPWR sky130_fd_sc_hd__decap_3
XFILLER_56_247 VGND VGND VPWR VPWR sky130_fd_sc_hd__decap_3
X_5086_ _5086_/A _5101_/B _5100_/B VGND VGND VPWR VPWR _5086_/X sky130_fd_sc_hd__and3_2
X_4106_ _7141_/Q _4434_/B1 _4103_/X _4105_/X VGND VGND VPWR VPWR _4106_/X sky130_fd_sc_hd__a211o_2
XFILLER_112_14 VGND VGND VPWR VPWR sky130_fd_sc_hd__decap_3
XFILLER_37_461 VGND VGND VPWR VPWR sky130_fd_sc_hd__decap_3
XFILLER_84_567 VGND VGND VPWR VPWR sky130_fd_sc_hd__decap_3
XFILLER_84_589 VGND VGND VPWR VPWR sky130_fd_sc_hd__decap_3
X_4037_ _4394_/A _4394_/B _4036_/X VGND VGND VPWR VPWR _4458_/A sky130_fd_sc_hd__or3b_2
XTAP_TAPCELL_ROW_55_916 VGND VPWR sky130_fd_sc_hd__tapvpwrvgnd_1
XFILLER_112_47 VGND VGND VPWR VPWR sky130_fd_sc_hd__decap_3
XFILLER_25_623 VGND VGND VPWR VPWR sky130_fd_sc_hd__fill_1
XFILLER_71_217 VGND VGND VPWR VPWR sky130_fd_sc_hd__decap_3
XTAP_TAPCELL_ROW_69_1081 VGND VPWR sky130_fd_sc_hd__tapvpwrvgnd_1
XFILLER_24_122 VGND VGND VPWR VPWR sky130_fd_sc_hd__decap_3
XFILLER_24_144 VGND VGND VPWR VPWR sky130_fd_sc_hd__decap_3
XFILLER_64_291 VGND VGND VPWR VPWR sky130_fd_sc_hd__fill_2
XFILLER_72_29 VGND VGND VPWR VPWR sky130_fd_sc_hd__decap_3
XFILLER_12_306 VGND VGND VPWR VPWR sky130_fd_sc_hd__fill_2
XTAP_TAPCELL_ROW_35_673 VGND VPWR sky130_fd_sc_hd__tapvpwrvgnd_1
XFILLER_12_339 VGND VGND VPWR VPWR sky130_fd_sc_hd__decap_3
XFILLER_24_188 VGND VGND VPWR VPWR sky130_fd_sc_hd__decap_3
XFILLER_40_659 VGND VGND VPWR VPWR sky130_fd_sc_hd__decap_3
X_4939_ _4764_/B _4379_/B _4938_/Y _4937_/A _4852_/A VGND VGND VPWR VPWR _4939_/X
+ sky130_fd_sc_hd__o32a_2
X_6609_ _6643_/A VGND VGND VPWR VPWR _6609_/Y sky130_fd_sc_hd__inv_2
XFILLER_106_400 VGND VGND VPWR VPWR sky130_fd_sc_hd__decap_3
XFILLER_4_527 VGND VGND VPWR VPWR sky130_fd_sc_hd__decap_3
XFILLER_21_99 VGND VGND VPWR VPWR sky130_fd_sc_hd__decap_3
XFILLER_97_15 VGND VGND VPWR VPWR sky130_fd_sc_hd__decap_3
XFILLER_106_488 VGND VGND VPWR VPWR sky130_fd_sc_hd__decap_3
XFILLER_79_328 VGND VGND VPWR VPWR sky130_fd_sc_hd__decap_3
XTAP_TAPCELL_ROW_7_332 VGND VPWR sky130_fd_sc_hd__tapvpwrvgnd_1
XFILLER_102_672 VGND VGND VPWR VPWR sky130_fd_sc_hd__decap_3
XFILLER_47_203 VGND VGND VPWR VPWR sky130_fd_sc_hd__decap_3
XFILLER_94_309 VGND VGND VPWR VPWR sky130_fd_sc_hd__decap_3
XFILLER_47_236 VGND VGND VPWR VPWR sky130_fd_sc_hd__decap_3
XFILLER_75_523 VGND VGND VPWR VPWR sky130_fd_sc_hd__decap_3
XFILLER_101_193 VGND VGND VPWR VPWR sky130_fd_sc_hd__fill_2
XFILLER_62_206 VGND VGND VPWR VPWR sky130_fd_sc_hd__decap_3
XFILLER_75_556 VGND VGND VPWR VPWR sky130_fd_sc_hd__decap_3
XFILLER_28_483 VGND VGND VPWR VPWR sky130_fd_sc_hd__decap_3
XFILLER_28_494 VGND VGND VPWR VPWR sky130_fd_sc_hd__decap_3
XFILLER_46_85 VGND VGND VPWR VPWR sky130_fd_sc_hd__decap_3
XFILLER_90_548 VGND VGND VPWR VPWR sky130_fd_sc_hd__decap_3
XFILLER_43_442 VGND VGND VPWR VPWR sky130_fd_sc_hd__decap_3
XFILLER_102_91 VGND VGND VPWR VPWR sky130_fd_sc_hd__decap_3
XFILLER_30_103 VGND VGND VPWR VPWR sky130_fd_sc_hd__decap_3
XFILLER_31_626 VGND VGND VPWR VPWR sky130_fd_sc_hd__decap_3
XFILLER_15_199 VGND VGND VPWR VPWR sky130_fd_sc_hd__decap_3
XFILLER_62_62 VGND VGND VPWR VPWR sky130_fd_sc_hd__decap_3
XFILLER_70_283 VGND VGND VPWR VPWR sky130_fd_sc_hd__decap_3
XFILLER_30_158 VGND VGND VPWR VPWR sky130_fd_sc_hd__decap_3
XFILLER_87_9 VGND VGND VPWR VPWR sky130_fd_sc_hd__decap_3
XFILLER_7_24 VGND VGND VPWR VPWR sky130_fd_sc_hd__decap_3
XTAP_TAPCELL_ROW_96_1406 VGND VPWR sky130_fd_sc_hd__tapvpwrvgnd_1
XFILLER_7_365 VGND VGND VPWR VPWR sky130_fd_sc_hd__fill_1
XFILLER_7_57 VGND VGND VPWR VPWR sky130_fd_sc_hd__decap_3
XFILLER_109_293 VGND VGND VPWR VPWR sky130_fd_sc_hd__fill_2
XFILLER_7_387 VGND VGND VPWR VPWR sky130_fd_sc_hd__decap_3
XFILLER_97_158 VGND VGND VPWR VPWR sky130_fd_sc_hd__fill_2
XFILLER_38_203 VGND VGND VPWR VPWR sky130_fd_sc_hd__decap_3
XFILLER_78_361 VGND VGND VPWR VPWR sky130_fd_sc_hd__decap_3
XFILLER_97_169 VGND VGND VPWR VPWR sky130_fd_sc_hd__decap_3
XFILLER_16_3 VGND VGND VPWR VPWR sky130_fd_sc_hd__decap_3
XFILLER_66_523 VGND VGND VPWR VPWR sky130_fd_sc_hd__decap_3
XFILLER_66_545 VGND VGND VPWR VPWR sky130_fd_sc_hd__decap_3
XFILLER_66_589 VGND VGND VPWR VPWR sky130_fd_sc_hd__decap_3
XFILLER_93_364 VGND VGND VPWR VPWR sky130_fd_sc_hd__fill_1
X_6960_ _6965_/CLK _6960_/D VGND VGND VPWR VPWR _6960_/Q sky130_fd_sc_hd__dfxtp_2
XFILLER_53_228 VGND VGND VPWR VPWR sky130_fd_sc_hd__decap_3
XFILLER_81_526 VGND VGND VPWR VPWR sky130_fd_sc_hd__fill_1
XFILLER_81_537 VGND VGND VPWR VPWR sky130_fd_sc_hd__decap_3
XFILLER_93_386 VGND VGND VPWR VPWR sky130_fd_sc_hd__decap_3
XTAP_TAPCELL_ROW_105_1513 VGND VPWR sky130_fd_sc_hd__tapvpwrvgnd_1
X_6891_ _7005_/CLK _6891_/D VGND VGND VPWR VPWR _6891_/Q sky130_fd_sc_hd__dfxtp_2
XFILLER_34_464 VGND VGND VPWR VPWR sky130_fd_sc_hd__decap_3
XFILLER_61_261 VGND VGND VPWR VPWR sky130_fd_sc_hd__decap_3
XFILLER_21_125 VGND VGND VPWR VPWR sky130_fd_sc_hd__decap_3
XTAP_TAPCELL_ROW_32_632 VGND VPWR sky130_fd_sc_hd__tapvpwrvgnd_1
XFILLER_21_158 VGND VGND VPWR VPWR sky130_fd_sc_hd__decap_3
XFILLER_21_169 VGND VGND VPWR VPWR sky130_fd_sc_hd__decap_3
X_4724_ _4720_/A _4655_/X _4658_/B VGND VGND VPWR VPWR _4724_/X sky130_fd_sc_hd__o21a_2
XTAP_TAPCELL_ROW_60_974 VGND VPWR sky130_fd_sc_hd__tapvpwrvgnd_1
XFILLER_107_208 VGND VGND VPWR VPWR sky130_fd_sc_hd__decap_3
X_4655_ _4610_/A _4765_/B _4611_/Y _4762_/A _4744_/B VGND VGND VPWR VPWR _4655_/X
+ sky130_fd_sc_hd__a221o_2
X_7374_ _7374_/CLK _7374_/D _6654_/Y VGND VGND VPWR VPWR _7374_/Q sky130_fd_sc_hd__dfrtp_2
Xhold800 _6792_/Q VGND VGND VPWR VPWR _6792_/D sky130_fd_sc_hd__dlygate4sd3_1
Xhold811 _6869_/Q VGND VGND VPWR VPWR _6869_/D sky130_fd_sc_hd__dlygate4sd3_1
X_3606_ _4614_/B _3603_/B _5146_/B1 VGND VGND VPWR VPWR _3606_/X sky130_fd_sc_hd__o21a_2
XTAP_TAPCELL_ROW_116_1642 VGND VPWR sky130_fd_sc_hd__tapvpwrvgnd_1
XFILLER_107_14 VGND VGND VPWR VPWR sky130_fd_sc_hd__decap_3
XFILLER_89_604 VGND VGND VPWR VPWR sky130_fd_sc_hd__decap_3
Xhold822 _6909_/Q VGND VGND VPWR VPWR _6909_/D sky130_fd_sc_hd__dlygate4sd3_1
Xhold833 _6861_/Q VGND VGND VPWR VPWR _6861_/D sky130_fd_sc_hd__dlygate4sd3_1
Xhold844 _7087_/Q VGND VGND VPWR VPWR _7087_/D sky130_fd_sc_hd__dlygate4sd3_1
Xhold855 _7069_/Q VGND VGND VPWR VPWR _7069_/D sky130_fd_sc_hd__dlygate4sd3_1
Xmax_cap563 _4294_/A VGND VGND VPWR VPWR _4612_/A sky130_fd_sc_hd__clkbuf_2
X_6325_ _6674_/A VGND VGND VPWR VPWR _6325_/Y sky130_fd_sc_hd__inv_2
X_3537_ _3427_/B _3618_/C _5057_/A _3527_/A _3536_/Y VGND VGND VPWR VPWR _3537_/X
+ sky130_fd_sc_hd__o221a_2
XTAP_TAPCELL_ROW_116_1653 VGND VPWR sky130_fd_sc_hd__tapvpwrvgnd_1
XFILLER_107_47 VGND VGND VPWR VPWR sky130_fd_sc_hd__decap_3
XFILLER_115_263 VGND VGND VPWR VPWR sky130_fd_sc_hd__decap_3
Xhold866 _7093_/Q VGND VGND VPWR VPWR _7093_/D sky130_fd_sc_hd__dlygate4sd3_1
Xhold877 _7092_/Q VGND VGND VPWR VPWR _7092_/D sky130_fd_sc_hd__dlygate4sd3_1
Xhold888 _7064_/Q VGND VGND VPWR VPWR _7064_/D sky130_fd_sc_hd__dlygate4sd3_1
Xmax_cap574 fanout39/X VGND VGND VPWR VPWR _6536_/A sky130_fd_sc_hd__buf_2
XFILLER_107_69 VGND VGND VPWR VPWR sky130_fd_sc_hd__decap_3
XFILLER_115_296 VGND VGND VPWR VPWR sky130_fd_sc_hd__decap_3
XFILLER_67_18 VGND VGND VPWR VPWR sky130_fd_sc_hd__decap_3
XFILLER_88_147 VGND VGND VPWR VPWR sky130_fd_sc_hd__fill_2
Xhold899 _7100_/Q VGND VGND VPWR VPWR _7100_/D sky130_fd_sc_hd__dlygate4sd3_1
X_3468_ _7281_/Q _5159_/S _4321_/A2 _7089_/Q _3467_/X VGND VGND VPWR VPWR _3468_/X
+ sky130_fd_sc_hd__a221o_2
XFILLER_103_469 VGND VGND VPWR VPWR sky130_fd_sc_hd__decap_3
XFILLER_69_361 VGND VGND VPWR VPWR sky130_fd_sc_hd__decap_3
XFILLER_76_309 VGND VGND VPWR VPWR sky130_fd_sc_hd__decap_3
X_5207_ _5207_/A _5217_/B VGND VGND VPWR VPWR _7225_/D sky130_fd_sc_hd__and2_2
X_3399_ _3977_/S _3399_/B VGND VGND VPWR VPWR _3449_/B sky130_fd_sc_hd__nor2_4
XTAP_TAPCELL_ROW_4_302 VGND VPWR sky130_fd_sc_hd__tapvpwrvgnd_1
XFILLER_29_236 VGND VGND VPWR VPWR sky130_fd_sc_hd__decap_3
X_5138_ _3665_/B _3914_/X _5138_/S VGND VGND VPWR VPWR _5138_/X sky130_fd_sc_hd__mux2_2
XFILLER_72_504 VGND VGND VPWR VPWR sky130_fd_sc_hd__decap_3
XFILLER_96_191 VGND VGND VPWR VPWR sky130_fd_sc_hd__decap_3
XFILLER_44_206 VGND VGND VPWR VPWR sky130_fd_sc_hd__decap_3
XFILLER_57_589 VGND VGND VPWR VPWR sky130_fd_sc_hd__decap_3
XFILLER_83_39 VGND VGND VPWR VPWR sky130_fd_sc_hd__fill_2
X_5069_ _6987_/Q _5069_/B VGND VGND VPWR VPWR _5069_/X sky130_fd_sc_hd__or2_2
XFILLER_16_44 VGND VGND VPWR VPWR sky130_fd_sc_hd__decap_3
XFILLER_25_442 VGND VGND VPWR VPWR sky130_fd_sc_hd__decap_3
XFILLER_13_615 VGND VGND VPWR VPWR sky130_fd_sc_hd__fill_1
XFILLER_16_77 VGND VGND VPWR VPWR sky130_fd_sc_hd__decap_3
XFILLER_25_464 VGND VGND VPWR VPWR sky130_fd_sc_hd__fill_2
XFILLER_25_486 VGND VGND VPWR VPWR sky130_fd_sc_hd__decap_3
XTAP_TAPCELL_ROW_80_1207 VGND VPWR sky130_fd_sc_hd__tapvpwrvgnd_1
XFILLER_12_114 VGND VGND VPWR VPWR sky130_fd_sc_hd__fill_1
XFILLER_13_659 VGND VGND VPWR VPWR sky130_fd_sc_hd__decap_3
XFILLER_80_581 VGND VGND VPWR VPWR sky130_fd_sc_hd__decap_3
XFILLER_32_21 VGND VGND VPWR VPWR sky130_fd_sc_hd__decap_3
XFILLER_32_32 VGND VGND VPWR VPWR sky130_fd_sc_hd__decap_3
XFILLER_32_65 VGND VGND VPWR VPWR sky130_fd_sc_hd__decap_3
XFILLER_8_129 VGND VGND VPWR VPWR sky130_fd_sc_hd__decap_3
XFILLER_20_180 VGND VGND VPWR VPWR sky130_fd_sc_hd__decap_3
XPHY_EDGE_ROW_112_Left_229 VGND VGND VPWR VPWR sky130_fd_sc_hd__decap_3
XFILLER_79_103 VGND VGND VPWR VPWR sky130_fd_sc_hd__decap_3
XTAP_TAPCELL_ROW_91_1347 VGND VPWR sky130_fd_sc_hd__tapvpwrvgnd_1
XFILLER_0_530 VGND VGND VPWR VPWR sky130_fd_sc_hd__fill_2
XFILLER_79_125 VGND VGND VPWR VPWR sky130_fd_sc_hd__decap_3
XFILLER_0_552 VGND VGND VPWR VPWR sky130_fd_sc_hd__decap_3
XFILLER_79_158 VGND VGND VPWR VPWR sky130_fd_sc_hd__decap_3
XFILLER_79_169 VGND VGND VPWR VPWR sky130_fd_sc_hd__decap_3
XFILLER_102_480 VGND VGND VPWR VPWR sky130_fd_sc_hd__decap_3
XFILLER_57_51 VGND VGND VPWR VPWR sky130_fd_sc_hd__decap_3
XFILLER_87_180 VGND VGND VPWR VPWR sky130_fd_sc_hd__decap_3
XFILLER_88_681 VGND VGND VPWR VPWR sky130_fd_sc_hd__decap_3
XFILLER_94_139 VGND VGND VPWR VPWR sky130_fd_sc_hd__fill_1
XFILLER_57_84 VGND VGND VPWR VPWR sky130_fd_sc_hd__decap_3
XFILLER_75_364 VGND VGND VPWR VPWR sky130_fd_sc_hd__decap_3
XFILLER_35_217 VGND VGND VPWR VPWR sky130_fd_sc_hd__decap_3
XFILLER_63_526 VGND VGND VPWR VPWR sky130_fd_sc_hd__decap_3
XFILLER_90_301 VGND VGND VPWR VPWR sky130_fd_sc_hd__decap_3
XFILLER_113_90 VGND VGND VPWR VPWR sky130_fd_sc_hd__decap_3
XFILLER_28_291 VGND VGND VPWR VPWR sky130_fd_sc_hd__decap_3
XFILLER_50_209 VGND VGND VPWR VPWR sky130_fd_sc_hd__fill_2
XFILLER_31_456 VGND VGND VPWR VPWR sky130_fd_sc_hd__decap_3
XTAP_TAPCELL_ROW_100_1454 VGND VPWR sky130_fd_sc_hd__tapvpwrvgnd_1
XFILLER_7_140 VGND VGND VPWR VPWR sky130_fd_sc_hd__decap_3
X_4440_ _4440_/A _4650_/B VGND VGND VPWR VPWR _4441_/B sky130_fd_sc_hd__nand2_2
XFILLER_112_200 VGND VGND VPWR VPWR sky130_fd_sc_hd__decap_3
X_4371_ _4371_/A _4371_/B VGND VGND VPWR VPWR _4371_/Y sky130_fd_sc_hd__nand2_2
XFILLER_98_401 VGND VGND VPWR VPWR sky130_fd_sc_hd__decap_3
XFILLER_112_233 VGND VGND VPWR VPWR sky130_fd_sc_hd__decap_3
XFILLER_3_390 VGND VGND VPWR VPWR sky130_fd_sc_hd__fill_2
X_7090_ clkload8/A _7090_/D _6370_/Y VGND VGND VPWR VPWR _7090_/Q sky130_fd_sc_hd__dfrtp_2
XFILLER_58_309 VGND VGND VPWR VPWR sky130_fd_sc_hd__decap_3
XFILLER_79_670 VGND VGND VPWR VPWR sky130_fd_sc_hd__fill_2
XFILLER_86_618 VGND VGND VPWR VPWR sky130_fd_sc_hd__decap_3
XFILLER_100_439 VGND VGND VPWR VPWR sky130_fd_sc_hd__decap_3
XFILLER_112_288 VGND VGND VPWR VPWR sky130_fd_sc_hd__decap_3
XFILLER_85_128 VGND VGND VPWR VPWR sky130_fd_sc_hd__decap_3
XTAP_TAPCELL_ROW_111_1583 VGND VPWR sky130_fd_sc_hd__tapvpwrvgnd_1
XFILLER_66_331 VGND VGND VPWR VPWR sky130_fd_sc_hd__decap_3
XFILLER_66_353 VGND VGND VPWR VPWR sky130_fd_sc_hd__fill_2
XFILLER_94_651 VGND VGND VPWR VPWR sky130_fd_sc_hd__decap_3
XFILLER_26_206 VGND VGND VPWR VPWR sky130_fd_sc_hd__decap_3
XFILLER_66_375 VGND VGND VPWR VPWR sky130_fd_sc_hd__decap_3
XFILLER_94_684 VGND VGND VPWR VPWR sky130_fd_sc_hd__decap_3
XFILLER_26_239 VGND VGND VPWR VPWR sky130_fd_sc_hd__decap_3
X_6943_ _6976_/CLK _6943_/D VGND VGND VPWR VPWR _6943_/Q sky130_fd_sc_hd__dfxtp_2
XFILLER_22_401 VGND VGND VPWR VPWR sky130_fd_sc_hd__decap_3
XFILLER_81_367 VGND VGND VPWR VPWR sky130_fd_sc_hd__decap_3
X_6874_ _6975_/CLK _6874_/D VGND VGND VPWR VPWR _6874_/Q sky130_fd_sc_hd__dfxtp_2
XTAP_TAPCELL_ROW_66_1040 VGND VPWR sky130_fd_sc_hd__tapvpwrvgnd_1
XFILLER_34_283 VGND VGND VPWR VPWR sky130_fd_sc_hd__decap_3
XTAP_TAPCELL_ROW_45_790 VGND VPWR sky130_fd_sc_hd__tapvpwrvgnd_1
X_4707_ _6998_/Q _6999_/Q _7000_/Q _4912_/A VGND VGND VPWR VPWR _4825_/B sky130_fd_sc_hd__and4_2
X_4638_ _4950_/A _4950_/B VGND VGND VPWR VPWR _4948_/B sky130_fd_sc_hd__and2_2
Xhold630 _6919_/Q VGND VGND VPWR VPWR _6919_/D sky130_fd_sc_hd__dlygate4sd3_1
XFILLER_116_561 VGND VGND VPWR VPWR sky130_fd_sc_hd__decap_3
XFILLER_116_583 VGND VGND VPWR VPWR sky130_fd_sc_hd__decap_3
XFILLER_78_17 VGND VGND VPWR VPWR sky130_fd_sc_hd__decap_3
XFILLER_89_423 VGND VGND VPWR VPWR sky130_fd_sc_hd__decap_3
X_7357_ _7386_/CLK _7357_/D _6637_/Y VGND VGND VPWR VPWR _7357_/Q sky130_fd_sc_hd__dfrtp_2
Xhold641 _6886_/Q VGND VGND VPWR VPWR _6886_/D sky130_fd_sc_hd__dlygate4sd3_1
Xhold652 _6887_/Q VGND VGND VPWR VPWR _6887_/D sky130_fd_sc_hd__dlygate4sd3_1
Xhold663 _6963_/Q VGND VGND VPWR VPWR _6963_/D sky130_fd_sc_hd__dlygate4sd3_1
X_4569_ _4569_/A _4577_/B VGND VGND VPWR VPWR _7296_/D sky130_fd_sc_hd__and2_2
XTAP_TAPCELL_ROW_77_1180 VGND VPWR sky130_fd_sc_hd__tapvpwrvgnd_1
XFILLER_1_349 VGND VGND VPWR VPWR sky130_fd_sc_hd__fill_2
X_7288_ clkload7/A _7288_/D _6568_/Y VGND VGND VPWR VPWR _7288_/Q sky130_fd_sc_hd__dfrtp_2
Xhold674 _6727_/Q VGND VGND VPWR VPWR _6727_/D sky130_fd_sc_hd__dlygate4sd3_1
Xhold685 _6818_/Q VGND VGND VPWR VPWR _6818_/D sky130_fd_sc_hd__dlygate4sd3_1
Xhold696 _6858_/Q VGND VGND VPWR VPWR _6858_/D sky130_fd_sc_hd__dlygate4sd3_1
X_6308_ _6672_/A VGND VGND VPWR VPWR _6308_/Y sky130_fd_sc_hd__inv_2
XFILLER_103_244 VGND VGND VPWR VPWR sky130_fd_sc_hd__fill_1
XFILLER_103_266 VGND VGND VPWR VPWR sky130_fd_sc_hd__decap_3
XFILLER_49_309 VGND VGND VPWR VPWR sky130_fd_sc_hd__decap_3
XFILLER_77_629 VGND VGND VPWR VPWR sky130_fd_sc_hd__decap_3
XFILLER_85_640 VGND VGND VPWR VPWR sky130_fd_sc_hd__decap_3
XFILLER_17_228 VGND VGND VPWR VPWR sky130_fd_sc_hd__decap_3
XFILLER_27_43 VGND VGND VPWR VPWR sky130_fd_sc_hd__decap_3
XFILLER_57_364 VGND VGND VPWR VPWR sky130_fd_sc_hd__fill_1
XFILLER_72_312 VGND VGND VPWR VPWR sky130_fd_sc_hd__decap_3
XFILLER_84_150 VGND VGND VPWR VPWR sky130_fd_sc_hd__decap_3
XFILLER_85_673 VGND VGND VPWR VPWR sky130_fd_sc_hd__decap_3
XFILLER_32_209 VGND VGND VPWR VPWR sky130_fd_sc_hd__decap_3
XFILLER_43_20 VGND VGND VPWR VPWR sky130_fd_sc_hd__decap_3
XFILLER_53_592 VGND VGND VPWR VPWR sky130_fd_sc_hd__decap_3
XTAP_TAPCELL_ROW_15_429 VGND VPWR sky130_fd_sc_hd__tapvpwrvgnd_1
XFILLER_43_42 VGND VGND VPWR VPWR sky130_fd_sc_hd__decap_3
XFILLER_40_286 VGND VGND VPWR VPWR sky130_fd_sc_hd__decap_3
XFILLER_43_75 VGND VGND VPWR VPWR sky130_fd_sc_hd__decap_3
XFILLER_9_449 VGND VGND VPWR VPWR sky130_fd_sc_hd__decap_3
XFILLER_9_427 VGND VGND VPWR VPWR sky130_fd_sc_hd__decap_3
XFILLER_5_611 VGND VGND VPWR VPWR sky130_fd_sc_hd__decap_3
XFILLER_4_121 VGND VGND VPWR VPWR sky130_fd_sc_hd__decap_3
XFILLER_5_655 VGND VGND VPWR VPWR sky130_fd_sc_hd__decap_3
XFILLER_5_688 VGND VGND VPWR VPWR sky130_fd_sc_hd__decap_3
XFILLER_4_187 VGND VGND VPWR VPWR sky130_fd_sc_hd__decap_3
XFILLER_4_47 VGND VGND VPWR VPWR sky130_fd_sc_hd__decap_3
XFILLER_68_72 VGND VGND VPWR VPWR sky130_fd_sc_hd__decap_3
XFILLER_95_404 VGND VGND VPWR VPWR sky130_fd_sc_hd__decap_3
XFILLER_0_371 VGND VGND VPWR VPWR sky130_fd_sc_hd__decap_3
XFILLER_0_382 VGND VGND VPWR VPWR sky130_fd_sc_hd__decap_3
XFILLER_68_94 VGND VGND VPWR VPWR sky130_fd_sc_hd__decap_3
XFILLER_95_437 VGND VGND VPWR VPWR sky130_fd_sc_hd__fill_2
XFILLER_0_393 VGND VGND VPWR VPWR sky130_fd_sc_hd__decap_3
XFILLER_48_331 VGND VGND VPWR VPWR sky130_fd_sc_hd__decap_3
XFILLER_48_353 VGND VGND VPWR VPWR sky130_fd_sc_hd__decap_3
XFILLER_76_640 VGND VGND VPWR VPWR sky130_fd_sc_hd__decap_3
XFILLER_36_515 VGND VGND VPWR VPWR sky130_fd_sc_hd__decap_3
XFILLER_48_375 VGND VGND VPWR VPWR sky130_fd_sc_hd__decap_3
XFILLER_75_172 VGND VGND VPWR VPWR sky130_fd_sc_hd__decap_3
XFILLER_76_684 VGND VGND VPWR VPWR sky130_fd_sc_hd__decap_3
XFILLER_82_109 VGND VGND VPWR VPWR sky130_fd_sc_hd__decap_3
XFILLER_84_71 VGND VGND VPWR VPWR sky130_fd_sc_hd__decap_3
XFILLER_90_131 VGND VGND VPWR VPWR sky130_fd_sc_hd__decap_3
Xplace312 _4577_/B VGND VGND VPWR VPWR _4595_/B sky130_fd_sc_hd__buf_2
Xplace301 _4361_/A VGND VGND VPWR VPWR _5086_/A sky130_fd_sc_hd__buf_2
XFILLER_63_367 VGND VGND VPWR VPWR sky130_fd_sc_hd__decap_3
XFILLER_91_676 VGND VGND VPWR VPWR sky130_fd_sc_hd__decap_3
Xplace345 _4272_/B VGND VGND VPWR VPWR _4394_/B sky130_fd_sc_hd__buf_2
Xplace334 _4349_/B1 VGND VGND VPWR VPWR _4430_/A2 sky130_fd_sc_hd__buf_2
Xplace323 _4205_/A VGND VGND VPWR VPWR _4142_/A sky130_fd_sc_hd__buf_2
XFILLER_44_592 VGND VGND VPWR VPWR sky130_fd_sc_hd__decap_3
XFILLER_90_197 VGND VGND VPWR VPWR sky130_fd_sc_hd__decap_3
Xplace378 _4348_/B1 VGND VGND VPWR VPWR _4428_/B1 sky130_fd_sc_hd__buf_2
Xplace389 _5666_/A VGND VGND VPWR VPWR _4997_/A1 sky130_fd_sc_hd__buf_2
Xplace367 _4832_/A VGND VGND VPWR VPWR _3833_/S sky130_fd_sc_hd__buf_2
Xplace356 _5126_/S VGND VGND VPWR VPWR _5080_/S sky130_fd_sc_hd__buf_2
XFILLER_16_294 VGND VGND VPWR VPWR sky130_fd_sc_hd__decap_3
XFILLER_31_253 VGND VGND VPWR VPWR sky130_fd_sc_hd__decap_3
X_3871_ _6785_/Q _3926_/B1 _3917_/B1 _6873_/Q VGND VGND VPWR VPWR _3871_/X sky130_fd_sc_hd__a22o_2
X_6590_ _6651_/A VGND VGND VPWR VPWR _6590_/Y sky130_fd_sc_hd__inv_2
XTAP_TAPCELL_ROW_42_760 VGND VPWR sky130_fd_sc_hd__tapvpwrvgnd_1
XFILLER_8_493 VGND VGND VPWR VPWR sky130_fd_sc_hd__fill_2
X_7211_ _7267_/CLK _7211_/D _6491_/Y VGND VGND VPWR VPWR _7211_/Q sky130_fd_sc_hd__dfrtp_2
X_4423_ _7080_/Q _4432_/A2 _4142_/A _4422_/X VGND VGND VPWR VPWR _4649_/B sky130_fd_sc_hd__o211ai_2
XTAP_TAPCELL_ROW_113_1612 VGND VPWR sky130_fd_sc_hd__tapvpwrvgnd_1
X_7142_ _7368_/CLK _7142_/D _6422_/Y VGND VGND VPWR VPWR _7142_/Q sky130_fd_sc_hd__dfrtp_2
X_4354_ _7038_/Q _4503_/S _4354_/B1 _7385_/Q VGND VGND VPWR VPWR _4355_/B sky130_fd_sc_hd__a22o_2
XFILLER_58_106 VGND VGND VPWR VPWR sky130_fd_sc_hd__decap_3
XFILLER_59_607 VGND VGND VPWR VPWR sky130_fd_sc_hd__decap_3
XFILLER_59_629 VGND VGND VPWR VPWR sky130_fd_sc_hd__decap_3
XFILLER_86_415 VGND VGND VPWR VPWR sky130_fd_sc_hd__decap_3
X_7073_ _7330_/CLK _7073_/D _6353_/Y VGND VGND VPWR VPWR _7073_/Q sky130_fd_sc_hd__dfrtp_2
X_3305_ _6983_/Q VGND VGND VPWR VPWR _3340_/B sky130_fd_sc_hd__inv_2
XFILLER_113_597 VGND VGND VPWR VPWR sky130_fd_sc_hd__decap_3
XFILLER_58_128 VGND VGND VPWR VPWR sky130_fd_sc_hd__decap_3
XFILLER_86_448 VGND VGND VPWR VPWR sky130_fd_sc_hd__decap_3
X_4285_ _7035_/Q _4534_/S _4332_/B1 _7382_/Q VGND VGND VPWR VPWR _4286_/B sky130_fd_sc_hd__a22o_2
XFILLER_104_15 VGND VGND VPWR VPWR sky130_fd_sc_hd__decap_3
XFILLER_27_526 VGND VGND VPWR VPWR sky130_fd_sc_hd__decap_3
XFILLER_54_301 VGND VGND VPWR VPWR sky130_fd_sc_hd__decap_3
XFILLER_66_150 VGND VGND VPWR VPWR sky130_fd_sc_hd__decap_3
XFILLER_66_172 VGND VGND VPWR VPWR sky130_fd_sc_hd__decap_3
XFILLER_67_673 VGND VGND VPWR VPWR sky130_fd_sc_hd__decap_3
XFILLER_82_610 VGND VGND VPWR VPWR sky130_fd_sc_hd__decap_3
XFILLER_27_559 VGND VGND VPWR VPWR sky130_fd_sc_hd__fill_1
XFILLER_81_131 VGND VGND VPWR VPWR sky130_fd_sc_hd__fill_1
XFILLER_82_654 VGND VGND VPWR VPWR sky130_fd_sc_hd__decap_3
XFILLER_14_209 VGND VGND VPWR VPWR sky130_fd_sc_hd__decap_3
XFILLER_82_687 VGND VGND VPWR VPWR sky130_fd_sc_hd__decap_3
X_6926_ _6965_/CLK _6926_/D VGND VGND VPWR VPWR _6926_/Q sky130_fd_sc_hd__dfxtp_2
XFILLER_35_592 VGND VGND VPWR VPWR sky130_fd_sc_hd__decap_3
XFILLER_54_389 VGND VGND VPWR VPWR sky130_fd_sc_hd__decap_3
XFILLER_81_186 VGND VGND VPWR VPWR sky130_fd_sc_hd__decap_3
XFILLER_22_242 VGND VGND VPWR VPWR sky130_fd_sc_hd__fill_2
XFILLER_80_29 VGND VGND VPWR VPWR sky130_fd_sc_hd__decap_3
Xfanout24 _6600_/A VGND VGND VPWR VPWR _6570_/A sky130_fd_sc_hd__buf_2
Xfanout35 fanout38/X VGND VGND VPWR VPWR _6640_/A sky130_fd_sc_hd__clkdlybuf4s25_1
Xfanout46 _6643_/A VGND VGND VPWR VPWR _6483_/A sky130_fd_sc_hd__buf_1
X_6857_ _6964_/CLK _6857_/D VGND VGND VPWR VPWR _6857_/Q sky130_fd_sc_hd__dfxtp_2
XFILLER_10_404 VGND VGND VPWR VPWR sky130_fd_sc_hd__decap_3
XFILLER_13_23 VGND VGND VPWR VPWR sky130_fd_sc_hd__decap_3
XFILLER_22_253 VGND VGND VPWR VPWR sky130_fd_sc_hd__fill_1
XFILLER_22_275 VGND VGND VPWR VPWR sky130_fd_sc_hd__decap_3
XFILLER_50_584 VGND VGND VPWR VPWR sky130_fd_sc_hd__decap_3
Xfanout57 _6285_/A VGND VGND VPWR VPWR _6685_/A sky130_fd_sc_hd__buf_1
Xfanout68 fanout72/X VGND VGND VPWR VPWR _6619_/A sky130_fd_sc_hd__clkdlybuf4s25_1
X_6788_ _6931_/CLK _6788_/D VGND VGND VPWR VPWR _6788_/Q sky130_fd_sc_hd__dfxtp_2
XFILLER_108_303 VGND VGND VPWR VPWR sky130_fd_sc_hd__decap_3
XFILLER_108_358 VGND VGND VPWR VPWR sky130_fd_sc_hd__decap_3
XTAP_TAPCELL_ROW_20_487 VGND VPWR sky130_fd_sc_hd__tapvpwrvgnd_1
XFILLER_2_603 VGND VGND VPWR VPWR sky130_fd_sc_hd__decap_3
XFILLER_116_391 VGND VGND VPWR VPWR sky130_fd_sc_hd__fill_1
XFILLER_1_102 VGND VGND VPWR VPWR sky130_fd_sc_hd__decap_3
XFILLER_1_113 VGND VGND VPWR VPWR sky130_fd_sc_hd__decap_3
XFILLER_2_636 VGND VGND VPWR VPWR sky130_fd_sc_hd__decap_3
XFILLER_89_220 VGND VGND VPWR VPWR sky130_fd_sc_hd__decap_3
XFILLER_1_146 VGND VGND VPWR VPWR sky130_fd_sc_hd__fill_1
XFILLER_2_669 VGND VGND VPWR VPWR sky130_fd_sc_hd__decap_3
XFILLER_77_437 VGND VGND VPWR VPWR sky130_fd_sc_hd__decap_3
XFILLER_58_651 VGND VGND VPWR VPWR sky130_fd_sc_hd__decap_3
XFILLER_38_64 VGND VGND VPWR VPWR sky130_fd_sc_hd__decap_3
XFILLER_57_150 VGND VGND VPWR VPWR sky130_fd_sc_hd__fill_2
XFILLER_57_161 VGND VGND VPWR VPWR sky130_fd_sc_hd__decap_3
XFILLER_64_109 VGND VGND VPWR VPWR sky130_fd_sc_hd__decap_3
Xhold1160 _7177_/Q VGND VGND VPWR VPWR _5306_/A0 sky130_fd_sc_hd__dlygate4sd3_1
XFILLER_45_323 VGND VGND VPWR VPWR sky130_fd_sc_hd__decap_3
XFILLER_57_183 VGND VGND VPWR VPWR sky130_fd_sc_hd__decap_3
XFILLER_73_632 VGND VGND VPWR VPWR sky130_fd_sc_hd__decap_3
Xhold1171 _7248_/Q VGND VGND VPWR VPWR _5157_/A0 sky130_fd_sc_hd__dlygate4sd3_1
Xhold1182 _7155_/Q VGND VGND VPWR VPWR _5352_/A0 sky130_fd_sc_hd__dlygate4sd3_1
Xhold1193 _7334_/Q VGND VGND VPWR VPWR _4491_/A0 sky130_fd_sc_hd__dlygate4sd3_1
XFILLER_54_41 VGND VGND VPWR VPWR sky130_fd_sc_hd__decap_3
XFILLER_73_676 VGND VGND VPWR VPWR sky130_fd_sc_hd__decap_3
XTAP_TAPCELL_ROW_86_1279 VGND VPWR sky130_fd_sc_hd__tapvpwrvgnd_1
XFILLER_26_592 VGND VGND VPWR VPWR sky130_fd_sc_hd__decap_3
XFILLER_54_74 VGND VGND VPWR VPWR sky130_fd_sc_hd__decap_3
XFILLER_60_315 VGND VGND VPWR VPWR sky130_fd_sc_hd__decap_3
XFILLER_72_197 VGND VGND VPWR VPWR sky130_fd_sc_hd__fill_1
XTAP_TAPCELL_ROW_28_587 VGND VPWR sky130_fd_sc_hd__tapvpwrvgnd_1
XFILLER_13_220 VGND VGND VPWR VPWR sky130_fd_sc_hd__decap_3
XFILLER_54_85 VGND VGND VPWR VPWR sky130_fd_sc_hd__decap_3
XFILLER_60_348 VGND VGND VPWR VPWR sky130_fd_sc_hd__decap_3
XFILLER_110_80 VGND VGND VPWR VPWR sky130_fd_sc_hd__decap_3
XFILLER_13_264 VGND VGND VPWR VPWR sky130_fd_sc_hd__decap_3
XFILLER_110_91 VGND VGND VPWR VPWR sky130_fd_sc_hd__decap_3
XFILLER_70_73 VGND VGND VPWR VPWR sky130_fd_sc_hd__decap_3
Xclkload16 _6972_/CLK VGND VGND VPWR VPWR clkload16/Y sky130_fd_sc_hd__clkinv_2
Xclkload27 _7267_/CLK VGND VGND VPWR VPWR clkload27/X sky130_fd_sc_hd__clkbuf_8
Xclkload38 _7372_/CLK VGND VGND VPWR VPWR clkload38/X sky130_fd_sc_hd__clkbuf_1
XFILLER_114_306 VGND VGND VPWR VPWR sky130_fd_sc_hd__fill_2
XFILLER_5_463 VGND VGND VPWR VPWR sky130_fd_sc_hd__decap_3
XFILLER_107_380 VGND VGND VPWR VPWR sky130_fd_sc_hd__decap_3
XFILLER_107_391 VGND VGND VPWR VPWR sky130_fd_sc_hd__fill_1
XFILLER_48_6 VGND VGND VPWR VPWR sky130_fd_sc_hd__fill_1
XFILLER_79_60 VGND VGND VPWR VPWR sky130_fd_sc_hd__decap_3
XFILLER_79_93 VGND VGND VPWR VPWR sky130_fd_sc_hd__fill_1
XFILLER_68_437 VGND VGND VPWR VPWR sky130_fd_sc_hd__decap_3
X_4070_ _7339_/Q _3945_/S _4428_/B1 _7147_/Q VGND VGND VPWR VPWR _4070_/X sky130_fd_sc_hd__a22o_2
XFILLER_110_589 VGND VGND VPWR VPWR sky130_fd_sc_hd__decap_3
XFILLER_48_150 VGND VGND VPWR VPWR sky130_fd_sc_hd__decap_3
XFILLER_49_662 VGND VGND VPWR VPWR sky130_fd_sc_hd__decap_3
XFILLER_49_673 VGND VGND VPWR VPWR sky130_fd_sc_hd__decap_3
XFILLER_95_81 VGND VGND VPWR VPWR sky130_fd_sc_hd__decap_3
XFILLER_36_312 VGND VGND VPWR VPWR sky130_fd_sc_hd__fill_2
XFILLER_64_643 VGND VGND VPWR VPWR sky130_fd_sc_hd__fill_1
XFILLER_64_654 VGND VGND VPWR VPWR sky130_fd_sc_hd__decap_3
XFILLER_63_153 VGND VGND VPWR VPWR sky130_fd_sc_hd__decap_3
XFILLER_64_687 VGND VGND VPWR VPWR sky130_fd_sc_hd__decap_3
XFILLER_51_326 VGND VGND VPWR VPWR sky130_fd_sc_hd__decap_3
XFILLER_51_337 VGND VGND VPWR VPWR sky130_fd_sc_hd__decap_3
X_4972_ _5661_/B VGND VGND VPWR VPWR _4973_/B sky130_fd_sc_hd__inv_2
XTAP_TAPCELL_ROW_63_1010 VGND VPWR sky130_fd_sc_hd__tapvpwrvgnd_1
XFILLER_51_359 VGND VGND VPWR VPWR sky130_fd_sc_hd__decap_3
X_6711_ _7406_/CLK _6711_/D VGND VGND VPWR VPWR _6711_/Q sky130_fd_sc_hd__dfxtp_2
X_3923_ _3923_/A1 _3922_/X _5104_/A VGND VGND VPWR VPWR _3923_/X sky130_fd_sc_hd__a21o_2
XFILLER_32_584 VGND VGND VPWR VPWR sky130_fd_sc_hd__decap_3
X_6642_ _6642_/A VGND VGND VPWR VPWR _6642_/Y sky130_fd_sc_hd__inv_2
X_3854_ _3725_/X _3851_/X _3853_/X _3735_/X VGND VGND VPWR VPWR _3854_/X sky130_fd_sc_hd__a22o_2
X_6573_ _6638_/A VGND VGND VPWR VPWR _6573_/Y sky130_fd_sc_hd__inv_2
X_3785_ _6837_/Q _3651_/Y _3656_/Y _6832_/Q _3784_/X VGND VGND VPWR VPWR _3785_/X
+ sky130_fd_sc_hd__a221o_2
Xoutput510 _4672_/B VGND VGND VPWR VPWR instruction_out[28] sky130_fd_sc_hd__clkdlybuf4s25_1
Xoutput543 _7007_/Q VGND VGND VPWR VPWR pc_out[30] sky130_fd_sc_hd__clkdlybuf4s25_1
Xoutput532 _6997_/Q VGND VGND VPWR VPWR pc_out[20] sky130_fd_sc_hd__clkdlybuf4s25_1
Xoutput521 _6987_/Q VGND VGND VPWR VPWR pc_out[10] sky130_fd_sc_hd__clkdlybuf4s25_1
X_4406_ _7402_/Q _4429_/B1 _4434_/B1 _7146_/Q _4405_/X VGND VGND VPWR VPWR _4406_/X
+ sky130_fd_sc_hd__a221o_2
XFILLER_5_90 VGND VGND VPWR VPWR sky130_fd_sc_hd__decap_3
X_7125_ clkload7/A _7125_/D _6405_/Y VGND VGND VPWR VPWR _7125_/Q sky130_fd_sc_hd__dfrtp_2
X_5386_ _5386_/A0 _4899_/X _5396_/S VGND VGND VPWR VPWR _7140_/D sky130_fd_sc_hd__mux2_2
XFILLER_99_540 VGND VGND VPWR VPWR sky130_fd_sc_hd__decap_3
XFILLER_101_501 VGND VGND VPWR VPWR sky130_fd_sc_hd__decap_3
XFILLER_101_523 VGND VGND VPWR VPWR sky130_fd_sc_hd__decap_3
XFILLER_115_14 VGND VGND VPWR VPWR sky130_fd_sc_hd__decap_3
XFILLER_59_415 VGND VGND VPWR VPWR sky130_fd_sc_hd__decap_3
XFILLER_86_223 VGND VGND VPWR VPWR sky130_fd_sc_hd__decap_3
X_4337_ _4394_/A _4337_/B _4336_/X VGND VGND VPWR VPWR _4365_/C sky130_fd_sc_hd__or3b_2
XFILLER_99_584 VGND VGND VPWR VPWR sky130_fd_sc_hd__decap_3
XFILLER_101_556 VGND VGND VPWR VPWR sky130_fd_sc_hd__decap_3
XFILLER_115_47 VGND VGND VPWR VPWR sky130_fd_sc_hd__decap_3
XFILLER_115_69 VGND VGND VPWR VPWR sky130_fd_sc_hd__decap_3
XFILLER_86_245 VGND VGND VPWR VPWR sky130_fd_sc_hd__decap_3
XFILLER_86_256 VGND VGND VPWR VPWR sky130_fd_sc_hd__decap_3
X_7056_ clkload8/A _7056_/D _6336_/Y VGND VGND VPWR VPWR _7056_/Q sky130_fd_sc_hd__dfstp_2
X_4268_ _7198_/Q _4268_/A2 _4354_/B1 _7390_/Q VGND VGND VPWR VPWR _4268_/X sky130_fd_sc_hd__a22o_2
XFILLER_101_589 VGND VGND VPWR VPWR sky130_fd_sc_hd__fill_2
XFILLER_55_632 VGND VGND VPWR VPWR sky130_fd_sc_hd__decap_3
X_4199_ _4380_/A _4380_/B VGND VGND VPWR VPWR _4381_/A sky130_fd_sc_hd__nand2_2
XFILLER_27_356 VGND VGND VPWR VPWR sky130_fd_sc_hd__fill_1
XFILLER_54_153 VGND VGND VPWR VPWR sky130_fd_sc_hd__fill_2
XFILLER_55_665 VGND VGND VPWR VPWR sky130_fd_sc_hd__decap_3
XFILLER_55_676 VGND VGND VPWR VPWR sky130_fd_sc_hd__decap_3
XFILLER_15_529 VGND VGND VPWR VPWR sky130_fd_sc_hd__decap_3
XFILLER_27_389 VGND VGND VPWR VPWR sky130_fd_sc_hd__decap_3
XFILLER_42_326 VGND VGND VPWR VPWR sky130_fd_sc_hd__decap_3
XFILLER_54_186 VGND VGND VPWR VPWR sky130_fd_sc_hd__fill_1
XFILLER_82_495 VGND VGND VPWR VPWR sky130_fd_sc_hd__decap_3
XFILLER_23_551 VGND VGND VPWR VPWR sky130_fd_sc_hd__decap_3
XFILLER_24_11 VGND VGND VPWR VPWR sky130_fd_sc_hd__decap_3
XFILLER_42_359 VGND VGND VPWR VPWR sky130_fd_sc_hd__decap_3
XFILLER_70_679 VGND VGND VPWR VPWR sky130_fd_sc_hd__decap_3
X_6909_ _6978_/CLK _6909_/D VGND VGND VPWR VPWR _6909_/Q sky130_fd_sc_hd__dfxtp_2
XTAP_TAPCELL_ROW_25_557 VGND VPWR sky130_fd_sc_hd__tapvpwrvgnd_1
XTAP_TAPCELL_ROW_25_546 VGND VPWR sky130_fd_sc_hd__tapvpwrvgnd_1
XFILLER_24_44 VGND VGND VPWR VPWR sky130_fd_sc_hd__decap_3
XFILLER_24_66 VGND VGND VPWR VPWR sky130_fd_sc_hd__decap_3
XTAP_TAPCELL_ROW_53_888 VGND VPWR sky130_fd_sc_hd__tapvpwrvgnd_1
XFILLER_10_234 VGND VGND VPWR VPWR sky130_fd_sc_hd__decap_3
XFILLER_109_623 VGND VGND VPWR VPWR sky130_fd_sc_hd__decap_3
XFILLER_10_256 VGND VGND VPWR VPWR sky130_fd_sc_hd__decap_3
XFILLER_109_656 VGND VGND VPWR VPWR sky130_fd_sc_hd__decap_3
XFILLER_40_32 VGND VGND VPWR VPWR sky130_fd_sc_hd__decap_3
XFILLER_6_238 VGND VGND VPWR VPWR sky130_fd_sc_hd__decap_3
XFILLER_108_144 VGND VGND VPWR VPWR sky130_fd_sc_hd__decap_3
XFILLER_2_433 VGND VGND VPWR VPWR sky130_fd_sc_hd__decap_3
XFILLER_104_383 VGND VGND VPWR VPWR sky130_fd_sc_hd__decap_3
XFILLER_49_52 VGND VGND VPWR VPWR sky130_fd_sc_hd__decap_3
XFILLER_77_212 VGND VGND VPWR VPWR sky130_fd_sc_hd__decap_3
XFILLER_1_26 VGND VGND VPWR VPWR sky130_fd_sc_hd__decap_3
XTAP_TAPCELL_ROW_88_1308 VGND VPWR sky130_fd_sc_hd__tapvpwrvgnd_1
XFILLER_18_312 VGND VGND VPWR VPWR sky130_fd_sc_hd__decap_3
XFILLER_46_621 VGND VGND VPWR VPWR sky130_fd_sc_hd__decap_3
XFILLER_18_345 VGND VGND VPWR VPWR sky130_fd_sc_hd__decap_3
XFILLER_46_654 VGND VGND VPWR VPWR sky130_fd_sc_hd__decap_3
XFILLER_92_259 VGND VGND VPWR VPWR sky130_fd_sc_hd__decap_3
XFILLER_18_389 VGND VGND VPWR VPWR sky130_fd_sc_hd__decap_3
XFILLER_33_337 VGND VGND VPWR VPWR sky130_fd_sc_hd__fill_1
XFILLER_45_164 VGND VGND VPWR VPWR sky130_fd_sc_hd__decap_3
XFILLER_45_175 VGND VGND VPWR VPWR sky130_fd_sc_hd__decap_3
XFILLER_46_687 VGND VGND VPWR VPWR sky130_fd_sc_hd__decap_3
XFILLER_61_635 VGND VGND VPWR VPWR sky130_fd_sc_hd__decap_3
XFILLER_65_95 VGND VGND VPWR VPWR sky130_fd_sc_hd__decap_3
XFILLER_73_473 VGND VGND VPWR VPWR sky130_fd_sc_hd__decap_3
XFILLER_33_359 VGND VGND VPWR VPWR sky130_fd_sc_hd__decap_3
XFILLER_60_123 VGND VGND VPWR VPWR sky130_fd_sc_hd__fill_2
XFILLER_61_668 VGND VGND VPWR VPWR sky130_fd_sc_hd__decap_3
XFILLER_61_679 VGND VGND VPWR VPWR sky130_fd_sc_hd__decap_3
XFILLER_60_156 VGND VGND VPWR VPWR sky130_fd_sc_hd__decap_3
XTAP_TAPCELL_ROW_99_1437 VGND VPWR sky130_fd_sc_hd__tapvpwrvgnd_1
X_3570_ _7157_/Q _3409_/X _4272_/B _3469_/B _3469_/A VGND VGND VPWR VPWR _3570_/X
+ sky130_fd_sc_hd__a2111o_2
XFILLER_115_615 VGND VGND VPWR VPWR sky130_fd_sc_hd__fill_1
XFILLER_115_626 VGND VGND VPWR VPWR sky130_fd_sc_hd__decap_3
XFILLER_114_103 VGND VGND VPWR VPWR sky130_fd_sc_hd__decap_3
XFILLER_114_136 VGND VGND VPWR VPWR sky130_fd_sc_hd__decap_3
XFILLER_115_659 VGND VGND VPWR VPWR sky130_fd_sc_hd__decap_3
X_5240_ _4788_/A _4788_/B _5238_/X _5240_/B2 VGND VGND VPWR VPWR _7210_/D sky130_fd_sc_hd__a22o_2
XFILLER_102_309 VGND VGND VPWR VPWR sky130_fd_sc_hd__fill_2
XFILLER_114_147 VGND VGND VPWR VPWR sky130_fd_sc_hd__decap_3
XFILLER_46_3 VGND VGND VPWR VPWR sky130_fd_sc_hd__decap_3
X_5171_ _5171_/A _5182_/B VGND VGND VPWR VPWR _7242_/D sky130_fd_sc_hd__and2_2
XPHY_EDGE_ROW_18_Right_18 VGND VGND VPWR VPWR sky130_fd_sc_hd__decap_3
XFILLER_110_320 VGND VGND VPWR VPWR sky130_fd_sc_hd__decap_3
XFILLER_110_331 VGND VGND VPWR VPWR sky130_fd_sc_hd__decap_3
XFILLER_68_234 VGND VGND VPWR VPWR sky130_fd_sc_hd__decap_3
XFILLER_68_256 VGND VGND VPWR VPWR sky130_fd_sc_hd__fill_2
X_4122_ _7204_/Q _3962_/S _4505_/S _7049_/Q _4121_/X VGND VGND VPWR VPWR _4122_/X
+ sky130_fd_sc_hd__a221o_2
XFILLER_110_375 VGND VGND VPWR VPWR sky130_fd_sc_hd__decap_3
XFILLER_28_109 VGND VGND VPWR VPWR sky130_fd_sc_hd__decap_3
XFILLER_96_576 VGND VGND VPWR VPWR sky130_fd_sc_hd__decap_3
XFILLER_96_598 VGND VGND VPWR VPWR sky130_fd_sc_hd__decap_3
X_4053_ _4054_/A _4456_/A VGND VGND VPWR VPWR _4055_/A sky130_fd_sc_hd__nor2_2
XFILLER_37_665 VGND VGND VPWR VPWR sky130_fd_sc_hd__decap_3
XFILLER_83_259 VGND VGND VPWR VPWR sky130_fd_sc_hd__decap_3
XTAP_TAPCELL_ROW_108_1544 VGND VPWR sky130_fd_sc_hd__tapvpwrvgnd_1
XFILLER_36_186 VGND VGND VPWR VPWR sky130_fd_sc_hd__decap_3
XFILLER_52_613 VGND VGND VPWR VPWR sky130_fd_sc_hd__decap_3
XFILLER_91_270 VGND VGND VPWR VPWR sky130_fd_sc_hd__decap_3
XFILLER_91_281 VGND VGND VPWR VPWR sky130_fd_sc_hd__decap_3
XFILLER_101_38 VGND VGND VPWR VPWR sky130_fd_sc_hd__fill_1
XFILLER_24_337 VGND VGND VPWR VPWR sky130_fd_sc_hd__decap_3
XFILLER_36_197 VGND VGND VPWR VPWR sky130_fd_sc_hd__decap_3
XFILLER_52_657 VGND VGND VPWR VPWR sky130_fd_sc_hd__decap_3
X_4955_ _5114_/A _4639_/A _4950_/A _5033_/B2 VGND VGND VPWR VPWR _4955_/X sky130_fd_sc_hd__a22o_2
XPHY_EDGE_ROW_27_Right_27 VGND VGND VPWR VPWR sky130_fd_sc_hd__decap_3
XFILLER_51_156 VGND VGND VPWR VPWR sky130_fd_sc_hd__fill_2
X_3906_ _6917_/Q _3906_/A2 _3906_/B1 _6691_/Q VGND VGND VPWR VPWR _3906_/X sky130_fd_sc_hd__a22o_2
XTAP_TAPCELL_ROW_22_516 VGND VPWR sky130_fd_sc_hd__tapvpwrvgnd_1
XFILLER_60_690 VGND VGND VPWR VPWR sky130_fd_sc_hd__fill_2
X_4886_ _4886_/A _4890_/B _4886_/C VGND VGND VPWR VPWR _4886_/X sky130_fd_sc_hd__or3_2
XTAP_TAPCELL_ROW_50_847 VGND VPWR sky130_fd_sc_hd__tapvpwrvgnd_1
XFILLER_20_565 VGND VGND VPWR VPWR sky130_fd_sc_hd__fill_1
X_6625_ _6660_/A VGND VGND VPWR VPWR _6625_/Y sky130_fd_sc_hd__inv_2
X_3837_ _6755_/Q _3853_/B1 _3665_/X _6767_/Q VGND VGND VPWR VPWR _3837_/X sky130_fd_sc_hd__a22o_2
X_6556_ _6647_/A VGND VGND VPWR VPWR _6556_/Y sky130_fd_sc_hd__inv_2
X_3768_ _6931_/Q _3926_/A2 _3862_/B1 _6795_/Q VGND VGND VPWR VPWR _3768_/X sky130_fd_sc_hd__a22o_2
XFILLER_106_637 VGND VGND VPWR VPWR sky130_fd_sc_hd__decap_3
XFILLER_106_648 VGND VGND VPWR VPWR sky130_fd_sc_hd__decap_3
XFILLER_10_24 VGND VGND VPWR VPWR sky130_fd_sc_hd__decap_3
XFILLER_10_35 VGND VGND VPWR VPWR sky130_fd_sc_hd__decap_3
X_6487_ _6584_/A VGND VGND VPWR VPWR _6487_/Y sky130_fd_sc_hd__inv_2
X_3699_ _6713_/Q _3767_/A2 _3826_/B1 _6891_/Q VGND VGND VPWR VPWR _3699_/X sky130_fd_sc_hd__a22o_2
XFILLER_105_169 VGND VGND VPWR VPWR sky130_fd_sc_hd__fill_2
XFILLER_10_68 VGND VGND VPWR VPWR sky130_fd_sc_hd__decap_3
XPHY_EDGE_ROW_36_Right_36 VGND VGND VPWR VPWR sky130_fd_sc_hd__decap_3
XFILLER_114_681 VGND VGND VPWR VPWR sky130_fd_sc_hd__decap_3
X_5369_ _5369_/A0 _4752_/X _5383_/S VGND VGND VPWR VPWR _7148_/D sky130_fd_sc_hd__mux2_2
XFILLER_99_381 VGND VGND VPWR VPWR sky130_fd_sc_hd__decap_3
XFILLER_101_320 VGND VGND VPWR VPWR sky130_fd_sc_hd__decap_3
XFILLER_19_11 VGND VGND VPWR VPWR sky130_fd_sc_hd__decap_3
XFILLER_59_223 VGND VGND VPWR VPWR sky130_fd_sc_hd__fill_1
XFILLER_59_234 VGND VGND VPWR VPWR sky130_fd_sc_hd__decap_3
XFILLER_87_532 VGND VGND VPWR VPWR sky130_fd_sc_hd__decap_3
X_7108_ _7330_/CLK _7108_/D _6388_/Y VGND VGND VPWR VPWR _7108_/Q sky130_fd_sc_hd__dfrtp_2
XFILLER_101_375 VGND VGND VPWR VPWR sky130_fd_sc_hd__decap_3
XFILLER_19_44 VGND VGND VPWR VPWR sky130_fd_sc_hd__decap_3
XFILLER_59_267 VGND VGND VPWR VPWR sky130_fd_sc_hd__decap_3
X_7039_ _7386_/CLK _7039_/D _6319_/Y VGND VGND VPWR VPWR _7039_/Q sky130_fd_sc_hd__dfrtp_2
XTAP_TAPCELL_ROW_58_947 VGND VPWR sky130_fd_sc_hd__tapvpwrvgnd_1
XFILLER_19_99 VGND VGND VPWR VPWR sky130_fd_sc_hd__decap_3
XFILLER_27_153 VGND VGND VPWR VPWR sky130_fd_sc_hd__decap_3
XTAP_TAPCELL_ROW_2_274 VGND VPWR sky130_fd_sc_hd__tapvpwrvgnd_1
XFILLER_15_326 VGND VGND VPWR VPWR sky130_fd_sc_hd__fill_1
XFILLER_27_175 VGND VGND VPWR VPWR sky130_fd_sc_hd__decap_3
XFILLER_35_32 VGND VGND VPWR VPWR sky130_fd_sc_hd__decap_3
XFILLER_43_635 VGND VGND VPWR VPWR sky130_fd_sc_hd__decap_3
XPHY_EDGE_ROW_45_Right_45 VGND VGND VPWR VPWR sky130_fd_sc_hd__decap_3
XFILLER_15_337 VGND VGND VPWR VPWR sky130_fd_sc_hd__decap_3
XFILLER_43_668 VGND VGND VPWR VPWR sky130_fd_sc_hd__decap_3
XFILLER_70_454 VGND VGND VPWR VPWR sky130_fd_sc_hd__decap_3
XTAP_TAPCELL_ROW_83_1249 VGND VPWR sky130_fd_sc_hd__tapvpwrvgnd_1
XFILLER_43_679 VGND VGND VPWR VPWR sky130_fd_sc_hd__decap_3
XFILLER_30_329 VGND VGND VPWR VPWR sky130_fd_sc_hd__decap_3
XFILLER_51_42 VGND VGND VPWR VPWR sky130_fd_sc_hd__decap_3
XFILLER_109_442 VGND VGND VPWR VPWR sky130_fd_sc_hd__decap_3
XFILLER_51_64 VGND VGND VPWR VPWR sky130_fd_sc_hd__decap_3
XFILLER_51_97 VGND VGND VPWR VPWR sky130_fd_sc_hd__decap_3
XFILLER_7_547 VGND VGND VPWR VPWR sky130_fd_sc_hd__decap_3
XFILLER_109_464 VGND VGND VPWR VPWR sky130_fd_sc_hd__decap_3
XPHY_EDGE_ROW_54_Right_54 VGND VGND VPWR VPWR sky130_fd_sc_hd__decap_3
XFILLER_112_607 VGND VGND VPWR VPWR sky130_fd_sc_hd__decap_3
XTAP_TAPCELL_ROW_94_1378 VGND VPWR sky130_fd_sc_hd__tapvpwrvgnd_1
XFILLER_105_670 VGND VGND VPWR VPWR sky130_fd_sc_hd__fill_2
XFILLER_78_510 VGND VGND VPWR VPWR sky130_fd_sc_hd__decap_3
XFILLER_78_554 VGND VGND VPWR VPWR sky130_fd_sc_hd__fill_1
XFILLER_76_61 VGND VGND VPWR VPWR sky130_fd_sc_hd__decap_3
XFILLER_78_587 VGND VGND VPWR VPWR sky130_fd_sc_hd__fill_1
XFILLER_19_610 VGND VGND VPWR VPWR sky130_fd_sc_hd__decap_3
XFILLER_65_237 VGND VGND VPWR VPWR sky130_fd_sc_hd__fill_2
XFILLER_93_546 VGND VGND VPWR VPWR sky130_fd_sc_hd__decap_3
XPHY_EDGE_ROW_63_Right_63 VGND VGND VPWR VPWR sky130_fd_sc_hd__decap_3
XFILLER_18_186 VGND VGND VPWR VPWR sky130_fd_sc_hd__decap_3
XFILLER_46_473 VGND VGND VPWR VPWR sky130_fd_sc_hd__decap_3
XFILLER_73_281 VGND VGND VPWR VPWR sky130_fd_sc_hd__fill_1
XFILLER_92_60 VGND VGND VPWR VPWR sky130_fd_sc_hd__decap_3
XFILLER_33_178 VGND VGND VPWR VPWR sky130_fd_sc_hd__decap_3
XFILLER_42_690 VGND VGND VPWR VPWR sky130_fd_sc_hd__fill_2
X_4740_ _4610_/A _4765_/B _4611_/Y _4762_/A _4948_/A VGND VGND VPWR VPWR _4740_/X
+ sky130_fd_sc_hd__a221o_2
XTAP_TAPCELL_ROW_103_1485 VGND VPWR sky130_fd_sc_hd__tapvpwrvgnd_1
X_4671_ _6991_/Q _4672_/B VGND VGND VPWR VPWR _4982_/B sky130_fd_sc_hd__and2_2
X_7390_ _7392_/CLK _7390_/D _6670_/Y VGND VGND VPWR VPWR _7390_/Q sky130_fd_sc_hd__dfrtp_2
X_6410_ _6539_/A VGND VGND VPWR VPWR _6410_/Y sky130_fd_sc_hd__inv_2
X_3622_ _4852_/A _5057_/A VGND VGND VPWR VPWR _3635_/B sky130_fd_sc_hd__nand2_2
X_6341_ _6347_/A VGND VGND VPWR VPWR _6341_/Y sky130_fd_sc_hd__inv_2
XPHY_EDGE_ROW_72_Right_72 VGND VGND VPWR VPWR sky130_fd_sc_hd__decap_3
X_3553_ _3469_/A _3469_/B _3449_/A _7253_/Q _3365_/A VGND VGND VPWR VPWR _3553_/X
+ sky130_fd_sc_hd__o2111a_2
X_6272_ _6523_/A VGND VGND VPWR VPWR _6272_/Y sky130_fd_sc_hd__inv_2
X_3484_ _4394_/A _4337_/B _3482_/Y _5153_/B VGND VGND VPWR VPWR _3485_/C sky130_fd_sc_hd__o31a_2
XFILLER_102_106 VGND VGND VPWR VPWR sky130_fd_sc_hd__decap_3
X_5223_ _5223_/A _5225_/B VGND VGND VPWR VPWR _7217_/D sky130_fd_sc_hd__and2_2
X_5154_ _5152_/Y _5153_/X _5587_/B VGND VGND VPWR VPWR _5154_/Y sky130_fd_sc_hd__a21oi_2
XFILLER_111_662 VGND VGND VPWR VPWR sky130_fd_sc_hd__decap_3
XFILLER_111_673 VGND VGND VPWR VPWR sky130_fd_sc_hd__decap_3
XFILLER_96_362 VGND VGND VPWR VPWR sky130_fd_sc_hd__fill_2
X_4105_ _7205_/Q _3949_/S _4429_/B1 _7397_/Q _4104_/X VGND VGND VPWR VPWR _4105_/X
+ sky130_fd_sc_hd__a221o_2
XPHY_EDGE_ROW_16_Left_133 VGND VGND VPWR VPWR sky130_fd_sc_hd__decap_3
XFILLER_2_80 VGND VGND VPWR VPWR sky130_fd_sc_hd__decap_3
X_5085_ _5086_/A _5084_/B _5084_/X VGND VGND VPWR VPWR _5085_/X sky130_fd_sc_hd__o21ba_2
XPHY_EDGE_ROW_81_Right_81 VGND VGND VPWR VPWR sky130_fd_sc_hd__decap_3
XFILLER_2_91 VGND VGND VPWR VPWR sky130_fd_sc_hd__decap_3
XFILLER_37_440 VGND VGND VPWR VPWR sky130_fd_sc_hd__decap_3
XFILLER_56_259 VGND VGND VPWR VPWR sky130_fd_sc_hd__decap_3
X_4036_ _7310_/Q _4772_/S _4434_/A2 _7118_/Q _4035_/X VGND VGND VPWR VPWR _4036_/X
+ sky130_fd_sc_hd__a221o_2
XTAP_TAPCELL_ROW_55_917 VGND VPWR sky130_fd_sc_hd__tapvpwrvgnd_1
XTAP_TAPCELL_ROW_55_906 VGND VPWR sky130_fd_sc_hd__tapvpwrvgnd_1
XFILLER_112_26 VGND VGND VPWR VPWR sky130_fd_sc_hd__fill_2
XFILLER_112_59 VGND VGND VPWR VPWR sky130_fd_sc_hd__decap_3
XFILLER_25_613 VGND VGND VPWR VPWR sky130_fd_sc_hd__decap_3
XFILLER_37_484 VGND VGND VPWR VPWR sky130_fd_sc_hd__decap_3
XFILLER_24_134 VGND VGND VPWR VPWR sky130_fd_sc_hd__decap_3
XFILLER_52_421 VGND VGND VPWR VPWR sky130_fd_sc_hd__decap_3
XTAP_TAPCELL_ROW_69_1082 VGND VPWR sky130_fd_sc_hd__tapvpwrvgnd_1
XFILLER_12_318 VGND VGND VPWR VPWR sky130_fd_sc_hd__decap_3
XFILLER_24_156 VGND VGND VPWR VPWR sky130_fd_sc_hd__decap_3
XTAP_TAPCELL_ROW_35_674 VGND VPWR sky130_fd_sc_hd__tapvpwrvgnd_1
XFILLER_52_498 VGND VGND VPWR VPWR sky130_fd_sc_hd__decap_3
X_4938_ _4938_/A _4938_/B VGND VGND VPWR VPWR _4938_/Y sky130_fd_sc_hd__nor2_2
X_4869_ _6999_/Q _4858_/B _4777_/A VGND VGND VPWR VPWR _4870_/B sky130_fd_sc_hd__o21ai_2
XPHY_EDGE_ROW_25_Left_142 VGND VGND VPWR VPWR sky130_fd_sc_hd__decap_3
XFILLER_20_362 VGND VGND VPWR VPWR sky130_fd_sc_hd__fill_2
XFILLER_20_373 VGND VGND VPWR VPWR sky130_fd_sc_hd__fill_1
XFILLER_21_12 VGND VGND VPWR VPWR sky130_fd_sc_hd__decap_3
X_6608_ _6608_/A VGND VGND VPWR VPWR _6608_/Y sky130_fd_sc_hd__inv_2
XPHY_EDGE_ROW_90_Right_90 VGND VGND VPWR VPWR sky130_fd_sc_hd__decap_3
X_6539_ _6539_/A VGND VGND VPWR VPWR _6539_/Y sky130_fd_sc_hd__inv_2
XFILLER_106_434 VGND VGND VPWR VPWR sky130_fd_sc_hd__decap_3
XFILLER_97_27 VGND VGND VPWR VPWR sky130_fd_sc_hd__decap_3
XFILLER_97_49 VGND VGND VPWR VPWR sky130_fd_sc_hd__decap_3
XFILLER_102_640 VGND VGND VPWR VPWR sky130_fd_sc_hd__decap_3
XTAP_TAPCELL_ROW_7_333 VGND VPWR sky130_fd_sc_hd__tapvpwrvgnd_1
XPHY_EDGE_ROW_34_Left_151 VGND VGND VPWR VPWR sky130_fd_sc_hd__decap_3
XFILLER_102_651 VGND VGND VPWR VPWR sky130_fd_sc_hd__decap_3
XFILLER_101_172 VGND VGND VPWR VPWR sky130_fd_sc_hd__decap_3
XFILLER_102_684 VGND VGND VPWR VPWR sky130_fd_sc_hd__decap_3
XFILLER_75_535 VGND VGND VPWR VPWR sky130_fd_sc_hd__decap_3
XFILLER_16_624 VGND VGND VPWR VPWR sky130_fd_sc_hd__decap_3
XFILLER_62_218 VGND VGND VPWR VPWR sky130_fd_sc_hd__decap_3
XFILLER_90_516 VGND VGND VPWR VPWR sky130_fd_sc_hd__fill_1
XFILLER_15_134 VGND VGND VPWR VPWR sky130_fd_sc_hd__fill_1
XFILLER_55_281 VGND VGND VPWR VPWR sky130_fd_sc_hd__decap_3
XFILLER_102_70 VGND VGND VPWR VPWR sky130_fd_sc_hd__decap_3
XFILLER_15_156 VGND VGND VPWR VPWR sky130_fd_sc_hd__decap_3
XFILLER_15_178 VGND VGND VPWR VPWR sky130_fd_sc_hd__decap_3
XFILLER_70_262 VGND VGND VPWR VPWR sky130_fd_sc_hd__decap_3
XFILLER_31_638 VGND VGND VPWR VPWR sky130_fd_sc_hd__decap_3
XFILLER_62_41 VGND VGND VPWR VPWR sky130_fd_sc_hd__decap_3
XPHY_EDGE_ROW_43_Left_160 VGND VGND VPWR VPWR sky130_fd_sc_hd__decap_3
XFILLER_62_74 VGND VGND VPWR VPWR sky130_fd_sc_hd__decap_3
XFILLER_62_85 VGND VGND VPWR VPWR sky130_fd_sc_hd__decap_3
XFILLER_7_36 VGND VGND VPWR VPWR sky130_fd_sc_hd__decap_3
XTAP_TAPCELL_ROW_96_1407 VGND VPWR sky130_fd_sc_hd__tapvpwrvgnd_1
XFILLER_109_250 VGND VGND VPWR VPWR sky130_fd_sc_hd__decap_3
XFILLER_116_209 VGND VGND VPWR VPWR sky130_fd_sc_hd__decap_3
XFILLER_7_69 VGND VGND VPWR VPWR sky130_fd_sc_hd__decap_3
XFILLER_3_561 VGND VGND VPWR VPWR sky130_fd_sc_hd__fill_1
XFILLER_98_638 VGND VGND VPWR VPWR sky130_fd_sc_hd__decap_3
XFILLER_112_437 VGND VGND VPWR VPWR sky130_fd_sc_hd__fill_2
XFILLER_112_448 VGND VGND VPWR VPWR sky130_fd_sc_hd__decap_3
XFILLER_97_137 VGND VGND VPWR VPWR sky130_fd_sc_hd__fill_1
XFILLER_78_351 VGND VGND VPWR VPWR sky130_fd_sc_hd__fill_1
XFILLER_87_71 VGND VGND VPWR VPWR sky130_fd_sc_hd__decap_3
XFILLER_87_93 VGND VGND VPWR VPWR sky130_fd_sc_hd__decap_3
XFILLER_38_215 VGND VGND VPWR VPWR sky130_fd_sc_hd__decap_3
XFILLER_38_226 VGND VGND VPWR VPWR sky130_fd_sc_hd__decap_3
XFILLER_78_384 VGND VGND VPWR VPWR sky130_fd_sc_hd__fill_1
XFILLER_38_259 VGND VGND VPWR VPWR sky130_fd_sc_hd__decap_3
XFILLER_66_568 VGND VGND VPWR VPWR sky130_fd_sc_hd__fill_2
XFILLER_81_505 VGND VGND VPWR VPWR sky130_fd_sc_hd__decap_3
XFILLER_93_343 VGND VGND VPWR VPWR sky130_fd_sc_hd__decap_3
XTAP_TAPCELL_ROW_105_1514 VGND VPWR sky130_fd_sc_hd__tapvpwrvgnd_1
XFILLER_34_421 VGND VGND VPWR VPWR sky130_fd_sc_hd__decap_3
X_6890_ _7406_/CLK _6890_/D VGND VGND VPWR VPWR _6890_/Q sky130_fd_sc_hd__dfxtp_2
XFILLER_61_240 VGND VGND VPWR VPWR sky130_fd_sc_hd__decap_3
XFILLER_61_273 VGND VGND VPWR VPWR sky130_fd_sc_hd__decap_3
XFILLER_61_284 VGND VGND VPWR VPWR sky130_fd_sc_hd__decap_3
XTAP_TAPCELL_ROW_32_633 VGND VPWR sky130_fd_sc_hd__tapvpwrvgnd_1
X_4723_ _3536_/B _4720_/A _4721_/Y _3526_/B VGND VGND VPWR VPWR _4723_/X sky130_fd_sc_hd__a22o_2
XTAP_TAPCELL_ROW_60_975 VGND VPWR sky130_fd_sc_hd__tapvpwrvgnd_1
X_4654_ _4646_/Y _4647_/X _4653_/Y _4788_/B VGND VGND VPWR VPWR _4762_/A sky130_fd_sc_hd__a211o_2
XTAP_TAPCELL_ROW_12_390 VGND VPWR sky130_fd_sc_hd__tapvpwrvgnd_1
X_7373_ _7374_/CLK _7373_/D _6653_/Y VGND VGND VPWR VPWR _7373_/Q sky130_fd_sc_hd__dfrtp_2
Xhold801 _6726_/Q VGND VGND VPWR VPWR _6726_/D sky130_fd_sc_hd__dlygate4sd3_1
Xhold812 _6853_/Q VGND VGND VPWR VPWR _6853_/D sky130_fd_sc_hd__dlygate4sd3_1
X_4585_ _4585_/A _4595_/B VGND VGND VPWR VPWR _7288_/D sky130_fd_sc_hd__and2_2
X_3605_ _3621_/A _3621_/B VGND VGND VPWR VPWR _3605_/Y sky130_fd_sc_hd__nor2b_2
XTAP_TAPCELL_ROW_116_1643 VGND VPWR sky130_fd_sc_hd__tapvpwrvgnd_1
XFILLER_115_220 VGND VGND VPWR VPWR sky130_fd_sc_hd__decap_3
XFILLER_115_231 VGND VGND VPWR VPWR sky130_fd_sc_hd__decap_3
Xhold823 _6728_/Q VGND VGND VPWR VPWR _6728_/D sky130_fd_sc_hd__dlygate4sd3_1
Xhold834 _6753_/Q VGND VGND VPWR VPWR _6753_/D sky130_fd_sc_hd__dlygate4sd3_1
Xhold845 _7074_/Q VGND VGND VPWR VPWR _7074_/D sky130_fd_sc_hd__dlygate4sd3_1
Xmax_cap553 _5657_/B VGND VGND VPWR VPWR _4913_/A1 sky130_fd_sc_hd__clkbuf_2
X_6324_ _6642_/A VGND VGND VPWR VPWR _6324_/Y sky130_fd_sc_hd__inv_2
X_3536_ _4614_/A _3536_/B VGND VGND VPWR VPWR _3536_/Y sky130_fd_sc_hd__nand2_2
XTAP_TAPCELL_ROW_116_1654 VGND VPWR sky130_fd_sc_hd__tapvpwrvgnd_1
XFILLER_103_415 VGND VGND VPWR VPWR sky130_fd_sc_hd__fill_2
XFILLER_107_26 VGND VGND VPWR VPWR sky130_fd_sc_hd__decap_3
XFILLER_115_275 VGND VGND VPWR VPWR sky130_fd_sc_hd__decap_3
Xhold856 _7096_/Q VGND VGND VPWR VPWR _7096_/D sky130_fd_sc_hd__dlygate4sd3_1
Xhold867 _7115_/Q VGND VGND VPWR VPWR _7115_/D sky130_fd_sc_hd__dlygate4sd3_1
Xhold878 _7070_/Q VGND VGND VPWR VPWR _7070_/D sky130_fd_sc_hd__dlygate4sd3_1
Xhold889 _7111_/Q VGND VGND VPWR VPWR _7111_/D sky130_fd_sc_hd__dlygate4sd3_1
Xmax_cap575 _6280_/A VGND VGND VPWR VPWR _6652_/A sky130_fd_sc_hd__buf_2
Xmax_cap564 _3535_/B VGND VGND VPWR VPWR _5071_/A sky130_fd_sc_hd__clkbuf_2
XFILLER_103_437 VGND VGND VPWR VPWR sky130_fd_sc_hd__decap_3
XFILLER_88_126 VGND VGND VPWR VPWR sky130_fd_sc_hd__decap_3
X_3467_ _7121_/Q _3407_/X _4352_/B1 _7153_/Q _3466_/X VGND VGND VPWR VPWR _3467_/X
+ sky130_fd_sc_hd__a221o_2
XFILLER_69_340 VGND VGND VPWR VPWR sky130_fd_sc_hd__decap_3
XFILLER_97_660 VGND VGND VPWR VPWR sky130_fd_sc_hd__decap_3
X_3398_ _4528_/B VGND VGND VPWR VPWR _3398_/Y sky130_fd_sc_hd__inv_2
XTAP_TAPCELL_ROW_4_303 VGND VPWR sky130_fd_sc_hd__tapvpwrvgnd_1
XFILLER_96_181 VGND VGND VPWR VPWR sky130_fd_sc_hd__decap_3
XFILLER_97_682 VGND VGND VPWR VPWR sky130_fd_sc_hd__decap_3
XFILLER_111_492 VGND VGND VPWR VPWR sky130_fd_sc_hd__decap_3
XFILLER_29_248 VGND VGND VPWR VPWR sky130_fd_sc_hd__decap_3
X_5068_ _6985_/Q _6986_/Q _5068_/C VGND VGND VPWR VPWR _5069_/B sky130_fd_sc_hd__and3_2
XFILLER_84_365 VGND VGND VPWR VPWR sky130_fd_sc_hd__decap_3
X_4019_ _7278_/Q _4437_/A2 _4430_/A2 _7246_/Q _4018_/X VGND VGND VPWR VPWR _4019_/X
+ sky130_fd_sc_hd__a221o_2
XFILLER_16_12 VGND VGND VPWR VPWR sky130_fd_sc_hd__decap_3
XFILLER_72_549 VGND VGND VPWR VPWR sky130_fd_sc_hd__decap_3
XFILLER_16_56 VGND VGND VPWR VPWR sky130_fd_sc_hd__decap_3
XFILLER_25_454 VGND VGND VPWR VPWR sky130_fd_sc_hd__fill_2
XFILLER_52_262 VGND VGND VPWR VPWR sky130_fd_sc_hd__decap_3
XFILLER_80_560 VGND VGND VPWR VPWR sky130_fd_sc_hd__decap_3
XTAP_TAPCELL_ROW_80_1208 VGND VPWR sky130_fd_sc_hd__tapvpwrvgnd_1
XPHY_EDGE_ROW_0_Right_0 VGND VGND VPWR VPWR sky130_fd_sc_hd__decap_3
XFILLER_13_638 VGND VGND VPWR VPWR sky130_fd_sc_hd__fill_1
XFILLER_40_424 VGND VGND VPWR VPWR sky130_fd_sc_hd__fill_1
XFILLER_52_295 VGND VGND VPWR VPWR sky130_fd_sc_hd__decap_3
XFILLER_40_446 VGND VGND VPWR VPWR sky130_fd_sc_hd__decap_3
XFILLER_9_609 VGND VGND VPWR VPWR sky130_fd_sc_hd__decap_3
XFILLER_32_44 VGND VGND VPWR VPWR sky130_fd_sc_hd__decap_3
XFILLER_32_77 VGND VGND VPWR VPWR sky130_fd_sc_hd__decap_3
XFILLER_32_88 VGND VGND VPWR VPWR sky130_fd_sc_hd__decap_3
XFILLER_113_3 VGND VGND VPWR VPWR sky130_fd_sc_hd__decap_3
XFILLER_106_220 VGND VGND VPWR VPWR sky130_fd_sc_hd__decap_3
XFILLER_79_137 VGND VGND VPWR VPWR sky130_fd_sc_hd__decap_3
XTAP_TAPCELL_ROW_91_1348 VGND VPWR sky130_fd_sc_hd__tapvpwrvgnd_1
XFILLER_48_502 VGND VGND VPWR VPWR sky130_fd_sc_hd__fill_2
XFILLER_88_660 VGND VGND VPWR VPWR sky130_fd_sc_hd__decap_3
XFILLER_95_608 VGND VGND VPWR VPWR sky130_fd_sc_hd__decap_3
XFILLER_57_30 VGND VGND VPWR VPWR sky130_fd_sc_hd__decap_3
XFILLER_75_310 VGND VGND VPWR VPWR sky130_fd_sc_hd__decap_3
XFILLER_94_118 VGND VGND VPWR VPWR sky130_fd_sc_hd__decap_3
XFILLER_102_492 VGND VGND VPWR VPWR sky130_fd_sc_hd__decap_3
XFILLER_57_63 VGND VGND VPWR VPWR sky130_fd_sc_hd__decap_3
XFILLER_75_343 VGND VGND VPWR VPWR sky130_fd_sc_hd__fill_1
XFILLER_63_516 VGND VGND VPWR VPWR sky130_fd_sc_hd__fill_2
XFILLER_63_538 VGND VGND VPWR VPWR sky130_fd_sc_hd__decap_3
XFILLER_16_421 VGND VGND VPWR VPWR sky130_fd_sc_hd__fill_2
XFILLER_90_357 VGND VGND VPWR VPWR sky130_fd_sc_hd__decap_3
XFILLER_16_465 VGND VGND VPWR VPWR sky130_fd_sc_hd__decap_3
XFILLER_31_402 VGND VGND VPWR VPWR sky130_fd_sc_hd__fill_1
XFILLER_43_251 VGND VGND VPWR VPWR sky130_fd_sc_hd__decap_3
XFILLER_73_73 VGND VGND VPWR VPWR sky130_fd_sc_hd__decap_3
XFILLER_90_379 VGND VGND VPWR VPWR sky130_fd_sc_hd__decap_3
XFILLER_16_498 VGND VGND VPWR VPWR sky130_fd_sc_hd__decap_3
XFILLER_31_424 VGND VGND VPWR VPWR sky130_fd_sc_hd__decap_3
XFILLER_71_582 VGND VGND VPWR VPWR sky130_fd_sc_hd__decap_3
XFILLER_73_84 VGND VGND VPWR VPWR sky130_fd_sc_hd__fill_1
XTAP_TAPCELL_ROW_100_1455 VGND VPWR sky130_fd_sc_hd__tapvpwrvgnd_1
XFILLER_8_642 VGND VGND VPWR VPWR sky130_fd_sc_hd__fill_2
XFILLER_7_152 VGND VGND VPWR VPWR sky130_fd_sc_hd__decap_3
X_4370_ _5100_/B _4361_/X _4362_/X _4369_/Y VGND VGND VPWR VPWR _5032_/B sky130_fd_sc_hd__a211o_2
X_3321_ _3369_/A _3353_/A VGND VGND VPWR VPWR _5294_/A sky130_fd_sc_hd__or2_4
XFILLER_98_413 VGND VGND VPWR VPWR sky130_fd_sc_hd__decap_3
XFILLER_112_212 VGND VGND VPWR VPWR sky130_fd_sc_hd__decap_3
XFILLER_98_435 VGND VGND VPWR VPWR sky130_fd_sc_hd__decap_3
XFILLER_112_267 VGND VGND VPWR VPWR sky130_fd_sc_hd__decap_3
XFILLER_85_107 VGND VGND VPWR VPWR sky130_fd_sc_hd__decap_3
XFILLER_79_682 VGND VGND VPWR VPWR sky130_fd_sc_hd__decap_3
XTAP_TAPCELL_ROW_111_1584 VGND VPWR sky130_fd_sc_hd__tapvpwrvgnd_1
XFILLER_78_192 VGND VGND VPWR VPWR sky130_fd_sc_hd__decap_3
XFILLER_94_641 VGND VGND VPWR VPWR sky130_fd_sc_hd__decap_3
XFILLER_94_663 VGND VGND VPWR VPWR sky130_fd_sc_hd__decap_3
XFILLER_54_505 VGND VGND VPWR VPWR sky130_fd_sc_hd__decap_3
XFILLER_66_365 VGND VGND VPWR VPWR sky130_fd_sc_hd__decap_3
XFILLER_66_387 VGND VGND VPWR VPWR sky130_fd_sc_hd__decap_3
XFILLER_93_162 VGND VGND VPWR VPWR sky130_fd_sc_hd__decap_3
XFILLER_19_281 VGND VGND VPWR VPWR sky130_fd_sc_hd__decap_3
XFILLER_81_324 VGND VGND VPWR VPWR sky130_fd_sc_hd__fill_1
XFILLER_81_335 VGND VGND VPWR VPWR sky130_fd_sc_hd__fill_1
XFILLER_81_346 VGND VGND VPWR VPWR sky130_fd_sc_hd__decap_3
X_6942_ _6959_/CLK _6942_/D VGND VGND VPWR VPWR _6942_/Q sky130_fd_sc_hd__dfxtp_2
XFILLER_34_251 VGND VGND VPWR VPWR sky130_fd_sc_hd__fill_1
XFILLER_62_560 VGND VGND VPWR VPWR sky130_fd_sc_hd__decap_3
XFILLER_81_379 VGND VGND VPWR VPWR sky130_fd_sc_hd__decap_3
X_6873_ _7384_/CLK _6873_/D VGND VGND VPWR VPWR _6873_/Q sky130_fd_sc_hd__dfxtp_2
XTAP_TAPCELL_ROW_66_1041 VGND VPWR sky130_fd_sc_hd__tapvpwrvgnd_1
XFILLER_22_424 VGND VGND VPWR VPWR sky130_fd_sc_hd__decap_3
XFILLER_34_262 VGND VGND VPWR VPWR sky130_fd_sc_hd__decap_3
XTAP_TAPCELL_ROW_45_791 VGND VPWR sky130_fd_sc_hd__tapvpwrvgnd_1
XTAP_TAPCELL_ROW_17_460 VGND VPWR sky130_fd_sc_hd__tapvpwrvgnd_1
XFILLER_34_295 VGND VGND VPWR VPWR sky130_fd_sc_hd__fill_2
X_5686_ _7349_/Q hold922/X _5721_/S VGND VGND VPWR VPWR _5686_/X sky130_fd_sc_hd__mux2_2
X_4706_ _6997_/Q _4931_/A VGND VGND VPWR VPWR _4912_/A sky130_fd_sc_hd__and2_2
XFILLER_108_518 VGND VGND VPWR VPWR sky130_fd_sc_hd__decap_3
X_4637_ _4380_/B _4637_/B _4637_/C VGND VGND VPWR VPWR _4950_/B sky130_fd_sc_hd__and3b_2
Xhold620 _6875_/Q VGND VGND VPWR VPWR _6875_/D sky130_fd_sc_hd__dlygate4sd3_1
XFILLER_116_551 VGND VGND VPWR VPWR sky130_fd_sc_hd__decap_3
XFILLER_78_29 VGND VGND VPWR VPWR sky130_fd_sc_hd__decap_3
XFILLER_89_402 VGND VGND VPWR VPWR sky130_fd_sc_hd__decap_3
X_7356_ _7356_/CLK _7356_/D _6636_/Y VGND VGND VPWR VPWR _7356_/Q sky130_fd_sc_hd__dfrtp_2
Xhold631 _6891_/Q VGND VGND VPWR VPWR _6891_/D sky130_fd_sc_hd__dlygate4sd3_1
Xhold642 _6903_/Q VGND VGND VPWR VPWR _6903_/D sky130_fd_sc_hd__dlygate4sd3_1
Xhold653 _6805_/Q VGND VGND VPWR VPWR _6805_/D sky130_fd_sc_hd__dlygate4sd3_1
XTAP_TAPCELL_ROW_77_1181 VGND VPWR sky130_fd_sc_hd__tapvpwrvgnd_1
XTAP_TAPCELL_ROW_77_1170 VGND VPWR sky130_fd_sc_hd__tapvpwrvgnd_1
XFILLER_103_223 VGND VGND VPWR VPWR sky130_fd_sc_hd__fill_1
XFILLER_116_595 VGND VGND VPWR VPWR sky130_fd_sc_hd__decap_3
X_7287_ clkload6/A _7287_/D _6567_/Y VGND VGND VPWR VPWR _7287_/Q sky130_fd_sc_hd__dfrtp_2
Xhold664 _6906_/Q VGND VGND VPWR VPWR _6906_/D sky130_fd_sc_hd__dlygate4sd3_1
Xhold675 _6768_/Q VGND VGND VPWR VPWR _6768_/D sky130_fd_sc_hd__dlygate4sd3_1
Xhold686 _6817_/Q VGND VGND VPWR VPWR _6817_/D sky130_fd_sc_hd__dlygate4sd3_1
Xhold697 _6946_/Q VGND VGND VPWR VPWR _6946_/D sky130_fd_sc_hd__dlygate4sd3_1
X_6307_ _6525_/A VGND VGND VPWR VPWR _6307_/Y sky130_fd_sc_hd__inv_2
X_4499_ _4499_/A0 _7298_/Q _4499_/S VGND VGND VPWR VPWR _7330_/D sky130_fd_sc_hd__mux2_2
X_3519_ _6979_/Q _3519_/B VGND VGND VPWR VPWR _3519_/Y sky130_fd_sc_hd__nor2_2
XFILLER_57_321 VGND VGND VPWR VPWR sky130_fd_sc_hd__decap_3
XFILLER_85_652 VGND VGND VPWR VPWR sky130_fd_sc_hd__decap_3
XFILLER_94_39 VGND VGND VPWR VPWR sky130_fd_sc_hd__decap_3
XFILLER_17_207 VGND VGND VPWR VPWR sky130_fd_sc_hd__decap_3
XFILLER_27_22 VGND VGND VPWR VPWR sky130_fd_sc_hd__decap_3
XFILLER_45_505 VGND VGND VPWR VPWR sky130_fd_sc_hd__decap_3
XFILLER_57_387 VGND VGND VPWR VPWR sky130_fd_sc_hd__decap_3
XFILLER_84_173 VGND VGND VPWR VPWR sky130_fd_sc_hd__decap_3
XFILLER_85_685 VGND VGND VPWR VPWR sky130_fd_sc_hd__decap_3
XFILLER_84_195 VGND VGND VPWR VPWR sky130_fd_sc_hd__fill_1
XFILLER_60_519 VGND VGND VPWR VPWR sky130_fd_sc_hd__fill_1
XFILLER_72_368 VGND VGND VPWR VPWR sky130_fd_sc_hd__fill_1
XFILLER_13_424 VGND VGND VPWR VPWR sky130_fd_sc_hd__decap_3
XFILLER_25_262 VGND VGND VPWR VPWR sky130_fd_sc_hd__decap_3
XFILLER_25_284 VGND VGND VPWR VPWR sky130_fd_sc_hd__fill_2
XFILLER_40_210 VGND VGND VPWR VPWR sky130_fd_sc_hd__fill_1
XFILLER_25_295 VGND VGND VPWR VPWR sky130_fd_sc_hd__decap_3
XFILLER_43_54 VGND VGND VPWR VPWR sky130_fd_sc_hd__fill_2
XFILLER_13_479 VGND VGND VPWR VPWR sky130_fd_sc_hd__decap_3
XFILLER_40_298 VGND VGND VPWR VPWR sky130_fd_sc_hd__decap_3
Xclkbuf_leaf_20_clk clkbuf_3_6__f_clk/X VGND VGND VPWR VPWR _7230_/CLK sky130_fd_sc_hd__clkbuf_16
XFILLER_4_100 VGND VGND VPWR VPWR sky130_fd_sc_hd__decap_3
XFILLER_4_133 VGND VGND VPWR VPWR sky130_fd_sc_hd__decap_3
XFILLER_5_634 VGND VGND VPWR VPWR sky130_fd_sc_hd__decap_3
XFILLER_107_573 VGND VGND VPWR VPWR sky130_fd_sc_hd__fill_1
XFILLER_4_144 VGND VGND VPWR VPWR sky130_fd_sc_hd__decap_3
XFILLER_4_15 VGND VGND VPWR VPWR sky130_fd_sc_hd__decap_3
XFILLER_5_667 VGND VGND VPWR VPWR sky130_fd_sc_hd__decap_3
XFILLER_107_595 VGND VGND VPWR VPWR sky130_fd_sc_hd__decap_3
XFILLER_108_80 VGND VGND VPWR VPWR sky130_fd_sc_hd__decap_3
XFILLER_4_59 VGND VGND VPWR VPWR sky130_fd_sc_hd__decap_3
XFILLER_108_91 VGND VGND VPWR VPWR sky130_fd_sc_hd__decap_3
XFILLER_68_51 VGND VGND VPWR VPWR sky130_fd_sc_hd__decap_3
XFILLER_68_608 VGND VGND VPWR VPWR sky130_fd_sc_hd__decap_3
XFILLER_0_350 VGND VGND VPWR VPWR sky130_fd_sc_hd__fill_1
XFILLER_67_129 VGND VGND VPWR VPWR sky130_fd_sc_hd__decap_3
XFILLER_95_416 VGND VGND VPWR VPWR sky130_fd_sc_hd__decap_3
XFILLER_95_449 VGND VGND VPWR VPWR sky130_fd_sc_hd__decap_3
XFILLER_48_343 VGND VGND VPWR VPWR sky130_fd_sc_hd__fill_2
XFILLER_76_652 VGND VGND VPWR VPWR sky130_fd_sc_hd__decap_3
XFILLER_48_365 VGND VGND VPWR VPWR sky130_fd_sc_hd__decap_3
XFILLER_63_313 VGND VGND VPWR VPWR sky130_fd_sc_hd__decap_3
XFILLER_76_663 VGND VGND VPWR VPWR sky130_fd_sc_hd__decap_3
XFILLER_84_50 VGND VGND VPWR VPWR sky130_fd_sc_hd__decap_3
XFILLER_63_346 VGND VGND VPWR VPWR sky130_fd_sc_hd__decap_3
XFILLER_75_184 VGND VGND VPWR VPWR sky130_fd_sc_hd__decap_3
XFILLER_84_83 VGND VGND VPWR VPWR sky130_fd_sc_hd__fill_1
XFILLER_90_121 VGND VGND VPWR VPWR sky130_fd_sc_hd__fill_2
XFILLER_91_655 VGND VGND VPWR VPWR sky130_fd_sc_hd__decap_3
Xplace313 _5274_/S VGND VGND VPWR VPWR _5262_/S sky130_fd_sc_hd__buf_2
Xplace302 _3635_/B VGND VGND VPWR VPWR _5033_/B2 sky130_fd_sc_hd__buf_2
XFILLER_63_379 VGND VGND VPWR VPWR sky130_fd_sc_hd__decap_3
XFILLER_91_688 VGND VGND VPWR VPWR sky130_fd_sc_hd__decap_3
Xplace346 _4337_/B VGND VGND VPWR VPWR _4272_/B sky130_fd_sc_hd__buf_2
Xplace335 _3377_/X VGND VGND VPWR VPWR _4349_/B1 sky130_fd_sc_hd__buf_2
Xplace324 _4460_/A VGND VGND VPWR VPWR _4205_/A sky130_fd_sc_hd__buf_2
XFILLER_16_273 VGND VGND VPWR VPWR sky130_fd_sc_hd__decap_3
Xplace379 _4348_/B1 VGND VGND VPWR VPWR _5229_/C sky130_fd_sc_hd__buf_2
Xplace368 _4799_/A VGND VGND VPWR VPWR _4832_/A sky130_fd_sc_hd__buf_2
Xplace357 _5136_/S VGND VGND VPWR VPWR _5126_/S sky130_fd_sc_hd__buf_2
XFILLER_31_232 VGND VGND VPWR VPWR sky130_fd_sc_hd__decap_3
X_3870_ _6760_/Q _3883_/A2 _3913_/B1 _6754_/Q _3869_/X VGND VGND VPWR VPWR _3870_/X
+ sky130_fd_sc_hd__a221o_2
XTAP_TAPCELL_ROW_42_761 VGND VPWR sky130_fd_sc_hd__tapvpwrvgnd_1
XTAP_TAPCELL_ROW_42_750 VGND VPWR sky130_fd_sc_hd__tapvpwrvgnd_1
XFILLER_31_287 VGND VGND VPWR VPWR sky130_fd_sc_hd__decap_3
XFILLER_76_3 VGND VGND VPWR VPWR sky130_fd_sc_hd__fill_1
Xclkbuf_leaf_11_clk clkbuf_leaf_4_clk/A VGND VGND VPWR VPWR _7401_/CLK sky130_fd_sc_hd__clkbuf_16
XFILLER_8_472 VGND VGND VPWR VPWR sky130_fd_sc_hd__decap_3
X_7210_ _7267_/CLK _7210_/D _6490_/Y VGND VGND VPWR VPWR _7210_/Q sky130_fd_sc_hd__dfrtp_2
X_4422_ _7272_/Q _4422_/A2 _4419_/X _4421_/X VGND VGND VPWR VPWR _4422_/X sky130_fd_sc_hd__a211o_2
XTAP_TAPCELL_ROW_113_1613 VGND VPWR sky130_fd_sc_hd__tapvpwrvgnd_1
XTAP_TAPCELL_ROW_113_1602 VGND VPWR sky130_fd_sc_hd__tapvpwrvgnd_1
X_7141_ _7365_/CLK _7141_/D _6421_/Y VGND VGND VPWR VPWR _7141_/Q sky130_fd_sc_hd__dfrtp_2
X_4353_ _7225_/Q _4469_/A3 _3968_/S _7193_/Q VGND VGND VPWR VPWR _4355_/A sky130_fd_sc_hd__a22o_2
XFILLER_98_232 VGND VGND VPWR VPWR sky130_fd_sc_hd__decap_3
XFILLER_113_543 VGND VGND VPWR VPWR sky130_fd_sc_hd__fill_1
X_7072_ _7330_/CLK _7072_/D _6352_/Y VGND VGND VPWR VPWR _7072_/Q sky130_fd_sc_hd__dfrtp_2
X_4284_ _7222_/Q _4331_/A2 _3979_/S _7190_/Q VGND VGND VPWR VPWR _4286_/A sky130_fd_sc_hd__a22o_2
X_3304_ _5129_/A _3353_/A VGND VGND VPWR VPWR _4696_/B sky130_fd_sc_hd__nand2_2
XFILLER_39_310 VGND VGND VPWR VPWR sky130_fd_sc_hd__decap_3
XFILLER_100_237 VGND VGND VPWR VPWR sky130_fd_sc_hd__decap_3
XFILLER_104_27 VGND VGND VPWR VPWR sky130_fd_sc_hd__fill_1
XFILLER_67_652 VGND VGND VPWR VPWR sky130_fd_sc_hd__decap_3
XFILLER_79_490 VGND VGND VPWR VPWR sky130_fd_sc_hd__decap_3
XFILLER_104_38 VGND VGND VPWR VPWR sky130_fd_sc_hd__decap_3
XFILLER_27_505 VGND VGND VPWR VPWR sky130_fd_sc_hd__fill_1
XFILLER_67_685 VGND VGND VPWR VPWR sky130_fd_sc_hd__decap_3
XFILLER_94_460 VGND VGND VPWR VPWR sky130_fd_sc_hd__decap_3
XFILLER_54_324 VGND VGND VPWR VPWR sky130_fd_sc_hd__decap_3
XFILLER_54_346 VGND VGND VPWR VPWR sky130_fd_sc_hd__decap_3
XFILLER_66_184 VGND VGND VPWR VPWR sky130_fd_sc_hd__decap_3
XFILLER_81_110 VGND VGND VPWR VPWR sky130_fd_sc_hd__fill_2
XFILLER_82_622 VGND VGND VPWR VPWR sky130_fd_sc_hd__decap_3
XFILLER_82_633 VGND VGND VPWR VPWR sky130_fd_sc_hd__decap_3
XFILLER_42_508 VGND VGND VPWR VPWR sky130_fd_sc_hd__fill_1
XFILLER_54_368 VGND VGND VPWR VPWR sky130_fd_sc_hd__decap_3
XFILLER_81_154 VGND VGND VPWR VPWR sky130_fd_sc_hd__decap_3
XFILLER_82_666 VGND VGND VPWR VPWR sky130_fd_sc_hd__decap_3
X_6925_ _6975_/CLK _6925_/D VGND VGND VPWR VPWR _6925_/Q sky130_fd_sc_hd__dfxtp_2
XFILLER_22_221 VGND VGND VPWR VPWR sky130_fd_sc_hd__decap_3
XFILLER_50_530 VGND VGND VPWR VPWR sky130_fd_sc_hd__fill_2
Xfanout25 _6664_/A VGND VGND VPWR VPWR _6635_/A sky130_fd_sc_hd__buf_2
Xfanout36 _6644_/A VGND VGND VPWR VPWR _6608_/A sky130_fd_sc_hd__buf_2
Xfanout47 fanout51/X VGND VGND VPWR VPWR _6643_/A sky130_fd_sc_hd__clkdlybuf4s25_1
X_6856_ _6959_/CLK _6856_/D VGND VGND VPWR VPWR _6856_/Q sky130_fd_sc_hd__dfxtp_2
Xfanout58 reset VGND VGND VPWR VPWR _6288_/A sky130_fd_sc_hd__buf_1
Xfanout69 _6523_/A VGND VGND VPWR VPWR _6553_/A sky130_fd_sc_hd__buf_2
X_6787_ _6931_/CLK _6787_/D VGND VGND VPWR VPWR _6787_/Q sky130_fd_sc_hd__dfxtp_2
XFILLER_13_35 VGND VGND VPWR VPWR sky130_fd_sc_hd__decap_3
XFILLER_13_57 VGND VGND VPWR VPWR sky130_fd_sc_hd__decap_3
XFILLER_22_287 VGND VGND VPWR VPWR sky130_fd_sc_hd__decap_3
XFILLER_108_315 VGND VGND VPWR VPWR sky130_fd_sc_hd__decap_3
XFILLER_6_409 VGND VGND VPWR VPWR sky130_fd_sc_hd__decap_3
XFILLER_108_337 VGND VGND VPWR VPWR sky130_fd_sc_hd__decap_3
XTAP_TAPCELL_ROW_20_488 VGND VPWR sky130_fd_sc_hd__tapvpwrvgnd_1
XFILLER_2_615 VGND VGND VPWR VPWR sky130_fd_sc_hd__decap_3
XFILLER_1_125 VGND VGND VPWR VPWR sky130_fd_sc_hd__decap_3
XFILLER_2_648 VGND VGND VPWR VPWR sky130_fd_sc_hd__decap_3
X_7339_ _7374_/CLK _7339_/D _6619_/Y VGND VGND VPWR VPWR _7339_/Q sky130_fd_sc_hd__dfrtp_2
XPHY_EDGE_ROW_8_Left_125 VGND VGND VPWR VPWR sky130_fd_sc_hd__decap_3
XFILLER_104_587 VGND VGND VPWR VPWR sky130_fd_sc_hd__fill_1
XFILLER_38_21 VGND VGND VPWR VPWR sky130_fd_sc_hd__decap_3
XFILLER_38_43 VGND VGND VPWR VPWR sky130_fd_sc_hd__decap_3
XFILLER_58_630 VGND VGND VPWR VPWR sky130_fd_sc_hd__decap_3
XFILLER_77_449 VGND VGND VPWR VPWR sky130_fd_sc_hd__decap_3
XFILLER_45_302 VGND VGND VPWR VPWR sky130_fd_sc_hd__decap_3
XFILLER_58_663 VGND VGND VPWR VPWR sky130_fd_sc_hd__decap_3
XFILLER_92_408 VGND VGND VPWR VPWR sky130_fd_sc_hd__decap_3
Xhold1150 _7329_/Q VGND VGND VPWR VPWR _4501_/A0 sky130_fd_sc_hd__dlygate4sd3_1
XFILLER_18_527 VGND VGND VPWR VPWR sky130_fd_sc_hd__decap_3
XFILLER_73_644 VGND VGND VPWR VPWR sky130_fd_sc_hd__fill_2
Xhold1161 _7304_/Q VGND VGND VPWR VPWR _4552_/A sky130_fd_sc_hd__dlygate4sd3_1
Xhold1172 _7148_/Q VGND VGND VPWR VPWR _5369_/A0 sky130_fd_sc_hd__dlygate4sd3_1
Xhold1183 _7298_/Q VGND VGND VPWR VPWR _4565_/A sky130_fd_sc_hd__dlygate4sd3_1
Xhold1194 _7179_/Q VGND VGND VPWR VPWR _5302_/A0 sky130_fd_sc_hd__dlygate4sd3_1
XFILLER_33_508 VGND VGND VPWR VPWR sky130_fd_sc_hd__decap_3
XFILLER_72_154 VGND VGND VPWR VPWR sky130_fd_sc_hd__decap_3
XFILLER_73_666 VGND VGND VPWR VPWR sky130_fd_sc_hd__fill_2
XFILLER_54_53 VGND VGND VPWR VPWR sky130_fd_sc_hd__decap_3
XFILLER_60_327 VGND VGND VPWR VPWR sky130_fd_sc_hd__decap_3
XFILLER_72_176 VGND VGND VPWR VPWR sky130_fd_sc_hd__decap_3
XTAP_TAPCELL_ROW_28_588 VGND VPWR sky130_fd_sc_hd__tapvpwrvgnd_1
XFILLER_13_243 VGND VGND VPWR VPWR sky130_fd_sc_hd__decap_3
XFILLER_41_541 VGND VGND VPWR VPWR sky130_fd_sc_hd__decap_3
XFILLER_54_97 VGND VGND VPWR VPWR sky130_fd_sc_hd__decap_3
XFILLER_9_225 VGND VGND VPWR VPWR sky130_fd_sc_hd__decap_3
XFILLER_13_287 VGND VGND VPWR VPWR sky130_fd_sc_hd__decap_3
XFILLER_70_41 VGND VGND VPWR VPWR sky130_fd_sc_hd__decap_3
Xclkload17 _6977_/CLK VGND VGND VPWR VPWR clkload17/X sky130_fd_sc_hd__clkbuf_1
XFILLER_62_9 VGND VGND VPWR VPWR sky130_fd_sc_hd__decap_3
Xclkload28 _7368_/CLK VGND VGND VPWR VPWR clkload28/Y sky130_fd_sc_hd__bufinv_16
XFILLER_114_318 VGND VGND VPWR VPWR sky130_fd_sc_hd__fill_2
XFILLER_114_329 VGND VGND VPWR VPWR sky130_fd_sc_hd__fill_1
XFILLER_79_72 VGND VGND VPWR VPWR sky130_fd_sc_hd__decap_3
XFILLER_68_416 VGND VGND VPWR VPWR sky130_fd_sc_hd__decap_3
XFILLER_95_202 VGND VGND VPWR VPWR sky130_fd_sc_hd__decap_3
XFILLER_49_641 VGND VGND VPWR VPWR sky130_fd_sc_hd__decap_3
XFILLER_48_162 VGND VGND VPWR VPWR sky130_fd_sc_hd__decap_3
XFILLER_49_685 VGND VGND VPWR VPWR sky130_fd_sc_hd__decap_3
XFILLER_95_268 VGND VGND VPWR VPWR sky130_fd_sc_hd__decap_3
XFILLER_95_93 VGND VGND VPWR VPWR sky130_fd_sc_hd__decap_3
Xclkbuf_leaf_0_clk clkload0/A VGND VGND VPWR VPWR clkload9/A sky130_fd_sc_hd__clkbuf_16
XFILLER_36_335 VGND VGND VPWR VPWR sky130_fd_sc_hd__decap_3
XFILLER_64_622 VGND VGND VPWR VPWR sky130_fd_sc_hd__decap_3
XTAP_TAPCELL_ROW_47_820 VGND VPWR sky130_fd_sc_hd__tapvpwrvgnd_1
XFILLER_24_508 VGND VGND VPWR VPWR sky130_fd_sc_hd__decap_3
XFILLER_36_368 VGND VGND VPWR VPWR sky130_fd_sc_hd__fill_2
XFILLER_64_666 VGND VGND VPWR VPWR sky130_fd_sc_hd__decap_3
XFILLER_91_441 VGND VGND VPWR VPWR sky130_fd_sc_hd__decap_3
XFILLER_51_305 VGND VGND VPWR VPWR sky130_fd_sc_hd__decap_3
XFILLER_63_165 VGND VGND VPWR VPWR sky130_fd_sc_hd__decap_3
XFILLER_63_176 VGND VGND VPWR VPWR sky130_fd_sc_hd__decap_3
X_4971_ _4811_/C _4949_/Y _4967_/X _4969_/X _4970_/X VGND VGND VPWR VPWR _5661_/B
+ sky130_fd_sc_hd__a311oi_2
X_6710_ _7387_/CLK _6710_/D VGND VGND VPWR VPWR _6710_/Q sky130_fd_sc_hd__dfxtp_2
X_3922_ _6778_/Q _3926_/B1 _3925_/B1 _6866_/Q _3921_/X VGND VGND VPWR VPWR _3922_/X
+ sky130_fd_sc_hd__a221o_2
XTAP_TAPCELL_ROW_63_1011 VGND VPWR sky130_fd_sc_hd__tapvpwrvgnd_1
X_6641_ _6674_/A VGND VGND VPWR VPWR _6641_/Y sky130_fd_sc_hd__inv_2
X_3853_ _6736_/Q _3886_/B1 _3853_/B1 _6730_/Q _3852_/X VGND VGND VPWR VPWR _3853_/X
+ sky130_fd_sc_hd__a221o_2
X_6572_ _6604_/A VGND VGND VPWR VPWR _6572_/Y sky130_fd_sc_hd__inv_2
X_3784_ _6847_/Q _3661_/X _3891_/B1 _6842_/Q VGND VGND VPWR VPWR _3784_/X sky130_fd_sc_hd__a22o_2
Xoutput511 _3509_/B VGND VGND VPWR VPWR instruction_out[2] sky130_fd_sc_hd__clkdlybuf4s25_1
Xoutput500 _5641_/Y VGND VGND VPWR VPWR instruction_out[17] sky130_fd_sc_hd__clkdlybuf4s25_1
Xoutput544 _7008_/Q VGND VGND VPWR VPWR pc_out[31] sky130_fd_sc_hd__clkdlybuf4s25_1
Xoutput533 _6998_/Q VGND VGND VPWR VPWR pc_out[21] sky130_fd_sc_hd__clkdlybuf4s25_1
Xoutput522 _6988_/Q VGND VGND VPWR VPWR pc_out[11] sky130_fd_sc_hd__clkdlybuf4s25_1
X_4405_ _7242_/Q _4433_/B _3949_/S _7210_/Q VGND VGND VPWR VPWR _4405_/X sky130_fd_sc_hd__a22o_2
X_7124_ clkload7/A _7124_/D _6404_/Y VGND VGND VPWR VPWR _7124_/Q sky130_fd_sc_hd__dfrtp_2
X_4336_ _4336_/A _4336_/B _4336_/C VGND VGND VPWR VPWR _4336_/X sky130_fd_sc_hd__or3_2
XTAP_TAPCELL_ROW_74_1140 VGND VPWR sky130_fd_sc_hd__tapvpwrvgnd_1
XFILLER_115_26 VGND VGND VPWR VPWR sky130_fd_sc_hd__decap_3
XFILLER_59_427 VGND VGND VPWR VPWR sky130_fd_sc_hd__decap_3
XFILLER_86_202 VGND VGND VPWR VPWR sky130_fd_sc_hd__decap_3
XFILLER_99_596 VGND VGND VPWR VPWR sky130_fd_sc_hd__decap_3
XFILLER_101_535 VGND VGND VPWR VPWR sky130_fd_sc_hd__decap_3
XFILLER_75_19 VGND VGND VPWR VPWR sky130_fd_sc_hd__decap_3
X_7055_ clkload9/A _7055_/D _6335_/Y VGND VGND VPWR VPWR _7055_/Q sky130_fd_sc_hd__dfrtp_2
X_4267_ _7134_/Q _4351_/B1 _4267_/B1 _7166_/Q VGND VGND VPWR VPWR _4271_/B sky130_fd_sc_hd__a22o_2
XFILLER_39_140 VGND VGND VPWR VPWR sky130_fd_sc_hd__decap_3
XFILLER_55_600 VGND VGND VPWR VPWR sky130_fd_sc_hd__decap_3
XFILLER_86_268 VGND VGND VPWR VPWR sky130_fd_sc_hd__decap_3
XFILLER_86_279 VGND VGND VPWR VPWR sky130_fd_sc_hd__fill_2
X_4198_ _4194_/X _4197_/X _4327_/A VGND VGND VPWR VPWR _4380_/B sky130_fd_sc_hd__o21ai_2
XFILLER_27_313 VGND VGND VPWR VPWR sky130_fd_sc_hd__decap_3
XFILLER_39_162 VGND VGND VPWR VPWR sky130_fd_sc_hd__decap_3
XFILLER_39_184 VGND VGND VPWR VPWR sky130_fd_sc_hd__decap_3
XFILLER_55_644 VGND VGND VPWR VPWR sky130_fd_sc_hd__decap_3
XFILLER_15_508 VGND VGND VPWR VPWR sky130_fd_sc_hd__decap_3
XFILLER_27_368 VGND VGND VPWR VPWR sky130_fd_sc_hd__decap_3
XFILLER_82_463 VGND VGND VPWR VPWR sky130_fd_sc_hd__fill_2
XFILLER_55_688 VGND VGND VPWR VPWR sky130_fd_sc_hd__decap_3
XFILLER_82_474 VGND VGND VPWR VPWR sky130_fd_sc_hd__fill_2
XFILLER_24_23 VGND VGND VPWR VPWR sky130_fd_sc_hd__decap_3
XFILLER_42_338 VGND VGND VPWR VPWR sky130_fd_sc_hd__decap_3
X_6908_ _6966_/CLK _6908_/D VGND VGND VPWR VPWR _6908_/Q sky130_fd_sc_hd__dfxtp_2
XTAP_TAPCELL_ROW_25_547 VGND VPWR sky130_fd_sc_hd__tapvpwrvgnd_1
X_6839_ _6929_/CLK _6839_/D VGND VGND VPWR VPWR _6839_/Q sky130_fd_sc_hd__dfxtp_2
XTAP_TAPCELL_ROW_53_889 VGND VPWR sky130_fd_sc_hd__tapvpwrvgnd_1
XFILLER_108_101 VGND VGND VPWR VPWR sky130_fd_sc_hd__decap_3
XFILLER_109_613 VGND VGND VPWR VPWR sky130_fd_sc_hd__decap_3
XFILLER_10_246 VGND VGND VPWR VPWR sky130_fd_sc_hd__decap_3
XFILLER_10_268 VGND VGND VPWR VPWR sky130_fd_sc_hd__decap_3
XFILLER_108_134 VGND VGND VPWR VPWR sky130_fd_sc_hd__decap_3
XFILLER_109_635 VGND VGND VPWR VPWR sky130_fd_sc_hd__decap_3
XFILLER_109_668 VGND VGND VPWR VPWR sky130_fd_sc_hd__decap_3
XFILLER_109_679 VGND VGND VPWR VPWR sky130_fd_sc_hd__decap_3
XFILLER_40_55 VGND VGND VPWR VPWR sky130_fd_sc_hd__decap_3
XFILLER_40_66 VGND VGND VPWR VPWR sky130_fd_sc_hd__decap_3
XFILLER_108_189 VGND VGND VPWR VPWR sky130_fd_sc_hd__decap_3
XFILLER_2_401 VGND VGND VPWR VPWR sky130_fd_sc_hd__decap_3
XFILLER_2_445 VGND VGND VPWR VPWR sky130_fd_sc_hd__decap_3
XFILLER_6_3 VGND VGND VPWR VPWR sky130_fd_sc_hd__decap_3
XFILLER_77_202 VGND VGND VPWR VPWR sky130_fd_sc_hd__fill_1
XFILLER_1_38 VGND VGND VPWR VPWR sky130_fd_sc_hd__decap_3
XFILLER_46_600 VGND VGND VPWR VPWR sky130_fd_sc_hd__decap_3
XFILLER_65_408 VGND VGND VPWR VPWR sky130_fd_sc_hd__decap_3
XFILLER_65_419 VGND VGND VPWR VPWR sky130_fd_sc_hd__decap_3
XFILLER_77_268 VGND VGND VPWR VPWR sky130_fd_sc_hd__decap_3
XTAP_TAPCELL_ROW_88_1309 VGND VPWR sky130_fd_sc_hd__tapvpwrvgnd_1
XFILLER_105_70 VGND VGND VPWR VPWR sky130_fd_sc_hd__decap_3
XFILLER_18_302 VGND VGND VPWR VPWR sky130_fd_sc_hd__decap_3
XFILLER_18_324 VGND VGND VPWR VPWR sky130_fd_sc_hd__decap_3
XFILLER_46_633 VGND VGND VPWR VPWR sky130_fd_sc_hd__decap_3
XFILLER_58_471 VGND VGND VPWR VPWR sky130_fd_sc_hd__decap_3
XFILLER_65_41 VGND VGND VPWR VPWR sky130_fd_sc_hd__decap_3
XFILLER_18_357 VGND VGND VPWR VPWR sky130_fd_sc_hd__decap_3
XFILLER_46_666 VGND VGND VPWR VPWR sky130_fd_sc_hd__decap_3
XFILLER_65_74 VGND VGND VPWR VPWR sky130_fd_sc_hd__decap_3
XFILLER_73_430 VGND VGND VPWR VPWR sky130_fd_sc_hd__decap_3
XFILLER_73_452 VGND VGND VPWR VPWR sky130_fd_sc_hd__decap_3
XFILLER_61_614 VGND VGND VPWR VPWR sky130_fd_sc_hd__fill_2
XFILLER_73_485 VGND VGND VPWR VPWR sky130_fd_sc_hd__decap_3
XFILLER_61_647 VGND VGND VPWR VPWR sky130_fd_sc_hd__decap_3
XFILLER_41_371 VGND VGND VPWR VPWR sky130_fd_sc_hd__fill_1
XFILLER_41_393 VGND VGND VPWR VPWR sky130_fd_sc_hd__fill_2
XTAP_TAPCELL_ROW_99_1438 VGND VPWR sky130_fd_sc_hd__tapvpwrvgnd_1
XFILLER_60_6 VGND VGND VPWR VPWR sky130_fd_sc_hd__fill_2
XFILLER_114_115 VGND VGND VPWR VPWR sky130_fd_sc_hd__decap_3
XFILLER_115_638 VGND VGND VPWR VPWR sky130_fd_sc_hd__decap_3
XFILLER_5_272 VGND VGND VPWR VPWR sky130_fd_sc_hd__decap_3
XFILLER_114_159 VGND VGND VPWR VPWR sky130_fd_sc_hd__decap_3
XFILLER_39_3 VGND VGND VPWR VPWR sky130_fd_sc_hd__decap_3
XFILLER_68_213 VGND VGND VPWR VPWR sky130_fd_sc_hd__decap_3
XFILLER_96_522 VGND VGND VPWR VPWR sky130_fd_sc_hd__decap_3
XFILLER_68_246 VGND VGND VPWR VPWR sky130_fd_sc_hd__decap_3
XFILLER_96_555 VGND VGND VPWR VPWR sky130_fd_sc_hd__decap_3
X_4121_ _7140_/Q _4195_/A2 _4267_/B1 _7172_/Q _4120_/X VGND VGND VPWR VPWR _4121_/X
+ sky130_fd_sc_hd__a221o_2
XFILLER_110_365 VGND VGND VPWR VPWR sky130_fd_sc_hd__decap_3
XFILLER_56_419 VGND VGND VPWR VPWR sky130_fd_sc_hd__fill_1
X_4052_ _4047_/X _4050_/X _4425_/A VGND VGND VPWR VPWR _4456_/A sky130_fd_sc_hd__o21a_2
XFILLER_37_633 VGND VGND VPWR VPWR sky130_fd_sc_hd__fill_2
XFILLER_83_216 VGND VGND VPWR VPWR sky130_fd_sc_hd__decap_3
XFILLER_83_238 VGND VGND VPWR VPWR sky130_fd_sc_hd__fill_1
XFILLER_36_132 VGND VGND VPWR VPWR sky130_fd_sc_hd__decap_3
XFILLER_37_644 VGND VGND VPWR VPWR sky130_fd_sc_hd__decap_3
XFILLER_64_430 VGND VGND VPWR VPWR sky130_fd_sc_hd__decap_3
XTAP_TAPCELL_ROW_108_1545 VGND VPWR sky130_fd_sc_hd__tapvpwrvgnd_1
XFILLER_52_625 VGND VGND VPWR VPWR sky130_fd_sc_hd__decap_3
XFILLER_64_463 VGND VGND VPWR VPWR sky130_fd_sc_hd__fill_2
XFILLER_24_349 VGND VGND VPWR VPWR sky130_fd_sc_hd__decap_3
XFILLER_52_669 VGND VGND VPWR VPWR sky130_fd_sc_hd__decap_3
X_4954_ _4186_/Y _4969_/C _4953_/Y _4200_/X VGND VGND VPWR VPWR _4954_/X sky130_fd_sc_hd__o211a_2
X_3905_ hold976/X _3909_/A2 _3904_/Y VGND VGND VPWR VPWR _7380_/D sky130_fd_sc_hd__a21bo_2
X_4885_ _4904_/B _4903_/A VGND VGND VPWR VPWR _4886_/C sky130_fd_sc_hd__and2b_2
XTAP_TAPCELL_ROW_50_848 VGND VPWR sky130_fd_sc_hd__tapvpwrvgnd_1
XTAP_TAPCELL_ROW_22_517 VGND VPWR sky130_fd_sc_hd__tapvpwrvgnd_1
X_6624_ _6660_/A VGND VGND VPWR VPWR _6624_/Y sky130_fd_sc_hd__inv_2
X_3836_ _6970_/Q _3853_/B1 _3917_/B1 _6720_/Q _3835_/X VGND VGND VPWR VPWR _3836_/X
+ sky130_fd_sc_hd__a221o_2
X_6555_ _6647_/A VGND VGND VPWR VPWR _6555_/Y sky130_fd_sc_hd__inv_2
X_3767_ _6705_/Q _3767_/A2 _3925_/B1 _6883_/Q VGND VGND VPWR VPWR _3767_/X sky130_fd_sc_hd__a22o_2
XPHY_EDGE_ROW_89_Left_206 VGND VGND VPWR VPWR sky130_fd_sc_hd__decap_3
XFILLER_105_104 VGND VGND VPWR VPWR sky130_fd_sc_hd__decap_3
X_6486_ _6684_/A VGND VGND VPWR VPWR _6486_/Y sky130_fd_sc_hd__inv_2
X_3698_ _3698_/A1 _4832_/A _3697_/Y VGND VGND VPWR VPWR _7402_/D sky130_fd_sc_hd__o21ba_2
XFILLER_105_159 VGND VGND VPWR VPWR sky130_fd_sc_hd__decap_3
XFILLER_10_47 VGND VGND VPWR VPWR sky130_fd_sc_hd__decap_3
XFILLER_114_660 VGND VGND VPWR VPWR sky130_fd_sc_hd__decap_3
XFILLER_59_202 VGND VGND VPWR VPWR sky130_fd_sc_hd__fill_2
XFILLER_86_29 VGND VGND VPWR VPWR sky130_fd_sc_hd__fill_1
XFILLER_87_511 VGND VGND VPWR VPWR sky130_fd_sc_hd__decap_3
XFILLER_99_360 VGND VGND VPWR VPWR sky130_fd_sc_hd__decap_3
XFILLER_101_332 VGND VGND VPWR VPWR sky130_fd_sc_hd__decap_3
XFILLER_113_181 VGND VGND VPWR VPWR sky130_fd_sc_hd__decap_3
XFILLER_59_246 VGND VGND VPWR VPWR sky130_fd_sc_hd__fill_2
X_7107_ _7363_/CLK _7107_/D _6387_/Y VGND VGND VPWR VPWR _7107_/Q sky130_fd_sc_hd__dfrtp_2
X_4319_ _7258_/Q _4601_/S _4316_/X _4318_/X VGND VGND VPWR VPWR _4362_/A sky130_fd_sc_hd__a211o_2
XFILLER_99_393 VGND VGND VPWR VPWR sky130_fd_sc_hd__decap_3
XFILLER_19_23 VGND VGND VPWR VPWR sky130_fd_sc_hd__decap_3
XFILLER_28_600 VGND VGND VPWR VPWR sky130_fd_sc_hd__decap_3
XFILLER_59_279 VGND VGND VPWR VPWR sky130_fd_sc_hd__fill_1
X_7038_ _7386_/CLK _7038_/D _6318_/Y VGND VGND VPWR VPWR _7038_/Q sky130_fd_sc_hd__dfrtp_2
XPHY_EDGE_ROW_98_Left_215 VGND VGND VPWR VPWR sky130_fd_sc_hd__decap_3
XFILLER_101_387 VGND VGND VPWR VPWR sky130_fd_sc_hd__decap_3
XFILLER_19_67 VGND VGND VPWR VPWR sky130_fd_sc_hd__decap_3
XFILLER_27_110 VGND VGND VPWR VPWR sky130_fd_sc_hd__fill_2
XFILLER_28_622 VGND VGND VPWR VPWR sky130_fd_sc_hd__decap_3
XTAP_TAPCELL_ROW_58_948 VGND VPWR sky130_fd_sc_hd__tapvpwrvgnd_1
XFILLER_67_290 VGND VGND VPWR VPWR sky130_fd_sc_hd__fill_1
XFILLER_15_305 VGND VGND VPWR VPWR sky130_fd_sc_hd__decap_3
XFILLER_27_165 VGND VGND VPWR VPWR sky130_fd_sc_hd__decap_3
XFILLER_55_463 VGND VGND VPWR VPWR sky130_fd_sc_hd__decap_3
XTAP_TAPCELL_ROW_2_275 VGND VPWR sky130_fd_sc_hd__tapvpwrvgnd_1
XFILLER_27_187 VGND VGND VPWR VPWR sky130_fd_sc_hd__decap_3
XFILLER_43_647 VGND VGND VPWR VPWR sky130_fd_sc_hd__decap_3
XFILLER_82_293 VGND VGND VPWR VPWR sky130_fd_sc_hd__decap_3
XFILLER_70_477 VGND VGND VPWR VPWR sky130_fd_sc_hd__decap_3
XFILLER_11_522 VGND VGND VPWR VPWR sky130_fd_sc_hd__fill_1
XFILLER_23_393 VGND VGND VPWR VPWR sky130_fd_sc_hd__decap_3
XFILLER_51_21 VGND VGND VPWR VPWR sky130_fd_sc_hd__decap_3
XFILLER_51_691 VGND VGND VPWR VPWR sky130_fd_sc_hd__fill_1
XFILLER_51_54 VGND VGND VPWR VPWR sky130_fd_sc_hd__fill_2
XFILLER_11_588 VGND VGND VPWR VPWR sky130_fd_sc_hd__decap_3
XFILLER_51_76 VGND VGND VPWR VPWR sky130_fd_sc_hd__decap_3
XTAP_TAPCELL_ROW_94_1379 VGND VPWR sky130_fd_sc_hd__tapvpwrvgnd_1
XFILLER_105_682 VGND VGND VPWR VPWR sky130_fd_sc_hd__decap_3
XFILLER_112_619 VGND VGND VPWR VPWR sky130_fd_sc_hd__decap_3
XFILLER_2_253 VGND VGND VPWR VPWR sky130_fd_sc_hd__decap_3
XFILLER_78_522 VGND VGND VPWR VPWR sky130_fd_sc_hd__decap_3
XFILLER_78_533 VGND VGND VPWR VPWR sky130_fd_sc_hd__fill_2
XFILLER_116_80 VGND VGND VPWR VPWR sky130_fd_sc_hd__decap_3
XFILLER_25_9 VGND VGND VPWR VPWR sky130_fd_sc_hd__fill_2
XFILLER_38_419 VGND VGND VPWR VPWR sky130_fd_sc_hd__fill_1
XFILLER_65_205 VGND VGND VPWR VPWR sky130_fd_sc_hd__decap_3
XFILLER_76_51 VGND VGND VPWR VPWR sky130_fd_sc_hd__decap_3
XFILLER_76_73 VGND VGND VPWR VPWR sky130_fd_sc_hd__decap_3
XFILLER_18_121 VGND VGND VPWR VPWR sky130_fd_sc_hd__decap_3
XFILLER_33_102 VGND VGND VPWR VPWR sky130_fd_sc_hd__decap_3
XFILLER_34_603 VGND VGND VPWR VPWR sky130_fd_sc_hd__fill_1
XFILLER_34_614 VGND VGND VPWR VPWR sky130_fd_sc_hd__decap_3
XFILLER_61_411 VGND VGND VPWR VPWR sky130_fd_sc_hd__decap_3
XFILLER_80_219 VGND VGND VPWR VPWR sky130_fd_sc_hd__decap_3
XFILLER_33_113 VGND VGND VPWR VPWR sky130_fd_sc_hd__decap_3
XFILLER_33_135 VGND VGND VPWR VPWR sky130_fd_sc_hd__decap_3
XFILLER_92_50 VGND VGND VPWR VPWR sky130_fd_sc_hd__decap_3
XFILLER_21_308 VGND VGND VPWR VPWR sky130_fd_sc_hd__fill_2
XFILLER_21_319 VGND VGND VPWR VPWR sky130_fd_sc_hd__decap_3
XFILLER_61_488 VGND VGND VPWR VPWR sky130_fd_sc_hd__decap_3
XFILLER_92_83 VGND VGND VPWR VPWR sky130_fd_sc_hd__fill_1
XFILLER_92_94 VGND VGND VPWR VPWR sky130_fd_sc_hd__decap_3
XFILLER_14_360 VGND VGND VPWR VPWR sky130_fd_sc_hd__decap_3
XTAP_TAPCELL_ROW_103_1486 VGND VPWR sky130_fd_sc_hd__tapvpwrvgnd_1
X_4670_ _6995_/Q _4672_/B VGND VGND VPWR VPWR _4682_/B sky130_fd_sc_hd__or2_2
X_3621_ _3621_/A _3621_/B VGND VGND VPWR VPWR _4852_/A sky130_fd_sc_hd__nand2_2
X_6340_ _6347_/A VGND VGND VPWR VPWR _6340_/Y sky130_fd_sc_hd__inv_2
X_3552_ _3508_/Y _5020_/A _3620_/A _3537_/X _3551_/X VGND VGND VPWR VPWR _3746_/A
+ sky130_fd_sc_hd__o311a_2
XFILLER_115_446 VGND VGND VPWR VPWR sky130_fd_sc_hd__fill_2
X_6271_ _6553_/A VGND VGND VPWR VPWR _6271_/Y sky130_fd_sc_hd__inv_2
X_3483_ _3442_/A _3442_/B _3409_/D VGND VGND VPWR VPWR _5153_/B sky130_fd_sc_hd__a21o_2
XFILLER_69_544 VGND VGND VPWR VPWR sky130_fd_sc_hd__decap_3
X_5153_ _7010_/D _5153_/B VGND VGND VPWR VPWR _5153_/X sky130_fd_sc_hd__xor2_2
XFILLER_111_641 VGND VGND VPWR VPWR sky130_fd_sc_hd__decap_3
XFILLER_29_408 VGND VGND VPWR VPWR sky130_fd_sc_hd__decap_3
XFILLER_69_577 VGND VGND VPWR VPWR sky130_fd_sc_hd__decap_3
XFILLER_96_341 VGND VGND VPWR VPWR sky130_fd_sc_hd__decap_3
X_4104_ _7237_/Q _4433_/B _4505_/S _7050_/Q VGND VGND VPWR VPWR _4104_/X sky130_fd_sc_hd__a22o_2
XFILLER_110_162 VGND VGND VPWR VPWR sky130_fd_sc_hd__decap_3
XFILLER_111_685 VGND VGND VPWR VPWR sky130_fd_sc_hd__decap_3
XFILLER_56_238 VGND VGND VPWR VPWR sky130_fd_sc_hd__decap_3
XFILLER_96_374 VGND VGND VPWR VPWR sky130_fd_sc_hd__decap_3
X_5084_ _4343_/X _5084_/B _5086_/A VGND VGND VPWR VPWR _5084_/X sky130_fd_sc_hd__and3b_2
XFILLER_37_430 VGND VGND VPWR VPWR sky130_fd_sc_hd__fill_1
XFILLER_37_452 VGND VGND VPWR VPWR sky130_fd_sc_hd__decap_3
XFILLER_49_290 VGND VGND VPWR VPWR sky130_fd_sc_hd__fill_2
XFILLER_84_558 VGND VGND VPWR VPWR sky130_fd_sc_hd__decap_3
X_4035_ _7374_/Q _4435_/B1 _4436_/B1 _7182_/Q _4034_/X VGND VGND VPWR VPWR _4035_/X
+ sky130_fd_sc_hd__a221o_2
XTAP_TAPCELL_ROW_55_907 VGND VPWR sky130_fd_sc_hd__tapvpwrvgnd_1
XFILLER_112_38 VGND VGND VPWR VPWR sky130_fd_sc_hd__decap_3
XFILLER_52_411 VGND VGND VPWR VPWR sky130_fd_sc_hd__decap_3
XFILLER_71_208 VGND VGND VPWR VPWR sky130_fd_sc_hd__decap_3
XFILLER_24_113 VGND VGND VPWR VPWR sky130_fd_sc_hd__decap_3
XFILLER_52_433 VGND VGND VPWR VPWR sky130_fd_sc_hd__decap_3
XTAP_TAPCELL_ROW_69_1083 VGND VPWR sky130_fd_sc_hd__tapvpwrvgnd_1
XFILLER_24_179 VGND VGND VPWR VPWR sky130_fd_sc_hd__decap_3
X_4937_ _4937_/A _4937_/B VGND VGND VPWR VPWR _4937_/Y sky130_fd_sc_hd__xnor2_2
XTAP_TAPCELL_ROW_35_675 VGND VPWR sky130_fd_sc_hd__tapvpwrvgnd_1
X_4868_ _6999_/Q _4882_/A VGND VGND VPWR VPWR _6999_/D sky130_fd_sc_hd__xnor2_2
X_6607_ _6608_/A VGND VGND VPWR VPWR _6607_/Y sky130_fd_sc_hd__inv_2
X_3819_ _6791_/Q _3862_/B1 _3925_/B1 _6879_/Q VGND VGND VPWR VPWR _3819_/X sky130_fd_sc_hd__a22o_2
XFILLER_21_35 VGND VGND VPWR VPWR sky130_fd_sc_hd__fill_1
X_4799_ _4799_/A _5656_/A VGND VGND VPWR VPWR _4799_/X sky130_fd_sc_hd__or2_2
XFILLER_106_424 VGND VGND VPWR VPWR sky130_fd_sc_hd__fill_1
XFILLER_21_57 VGND VGND VPWR VPWR sky130_fd_sc_hd__decap_3
X_6538_ _6539_/A VGND VGND VPWR VPWR _6538_/Y sky130_fd_sc_hd__inv_2
XFILLER_106_446 VGND VGND VPWR VPWR sky130_fd_sc_hd__fill_2
XFILLER_108_6 VGND VGND VPWR VPWR sky130_fd_sc_hd__decap_3
X_6469_ _6535_/A VGND VGND VPWR VPWR _6469_/Y sky130_fd_sc_hd__inv_2
XFILLER_106_468 VGND VGND VPWR VPWR sky130_fd_sc_hd__decap_3
XFILLER_97_39 VGND VGND VPWR VPWR sky130_fd_sc_hd__fill_2
XTAP_TAPCELL_ROW_7_334 VGND VPWR sky130_fd_sc_hd__tapvpwrvgnd_1
XFILLER_101_140 VGND VGND VPWR VPWR sky130_fd_sc_hd__decap_3
XFILLER_102_663 VGND VGND VPWR VPWR sky130_fd_sc_hd__decap_3
XFILLER_75_503 VGND VGND VPWR VPWR sky130_fd_sc_hd__fill_1
XPHY_EDGE_ROW_102_Right_102 VGND VGND VPWR VPWR sky130_fd_sc_hd__decap_3
XFILLER_75_514 VGND VGND VPWR VPWR sky130_fd_sc_hd__decap_3
XFILLER_101_184 VGND VGND VPWR VPWR sky130_fd_sc_hd__decap_3
XFILLER_46_21 VGND VGND VPWR VPWR sky130_fd_sc_hd__decap_3
XFILLER_46_43 VGND VGND VPWR VPWR sky130_fd_sc_hd__decap_3
XFILLER_46_65 VGND VGND VPWR VPWR sky130_fd_sc_hd__decap_3
XFILLER_55_260 VGND VGND VPWR VPWR sky130_fd_sc_hd__decap_3
XFILLER_90_539 VGND VGND VPWR VPWR sky130_fd_sc_hd__decap_3
XFILLER_43_433 VGND VGND VPWR VPWR sky130_fd_sc_hd__fill_2
XFILLER_55_293 VGND VGND VPWR VPWR sky130_fd_sc_hd__decap_3
XFILLER_102_82 VGND VGND VPWR VPWR sky130_fd_sc_hd__fill_2
XFILLER_43_455 VGND VGND VPWR VPWR sky130_fd_sc_hd__decap_3
XFILLER_62_20 VGND VGND VPWR VPWR sky130_fd_sc_hd__decap_3
XFILLER_30_127 VGND VGND VPWR VPWR sky130_fd_sc_hd__fill_2
XFILLER_62_53 VGND VGND VPWR VPWR sky130_fd_sc_hd__fill_1
XFILLER_70_274 VGND VGND VPWR VPWR sky130_fd_sc_hd__decap_3
XFILLER_70_296 VGND VGND VPWR VPWR sky130_fd_sc_hd__decap_3
XFILLER_23_190 VGND VGND VPWR VPWR sky130_fd_sc_hd__fill_2
XFILLER_62_97 VGND VGND VPWR VPWR sky130_fd_sc_hd__decap_3
XFILLER_7_15 VGND VGND VPWR VPWR sky130_fd_sc_hd__decap_3
XFILLER_7_301 VGND VGND VPWR VPWR sky130_fd_sc_hd__decap_3
XTAP_TAPCELL_ROW_96_1408 VGND VPWR sky130_fd_sc_hd__tapvpwrvgnd_1
XFILLER_11_396 VGND VGND VPWR VPWR sky130_fd_sc_hd__decap_3
XFILLER_7_48 VGND VGND VPWR VPWR sky130_fd_sc_hd__decap_3
XFILLER_109_273 VGND VGND VPWR VPWR sky130_fd_sc_hd__fill_1
XFILLER_109_284 VGND VGND VPWR VPWR sky130_fd_sc_hd__decap_3
XFILLER_97_116 VGND VGND VPWR VPWR sky130_fd_sc_hd__decap_3
XFILLER_98_628 VGND VGND VPWR VPWR sky130_fd_sc_hd__fill_1
XFILLER_112_427 VGND VGND VPWR VPWR sky130_fd_sc_hd__fill_2
XFILLER_97_149 VGND VGND VPWR VPWR sky130_fd_sc_hd__decap_3
XFILLER_23_6 VGND VGND VPWR VPWR sky130_fd_sc_hd__decap_3
XFILLER_78_330 VGND VGND VPWR VPWR sky130_fd_sc_hd__decap_3
XFILLER_19_430 VGND VGND VPWR VPWR sky130_fd_sc_hd__decap_3
XFILLER_38_249 VGND VGND VPWR VPWR sky130_fd_sc_hd__decap_3
XFILLER_93_355 VGND VGND VPWR VPWR sky130_fd_sc_hd__decap_3
XFILLER_46_260 VGND VGND VPWR VPWR sky130_fd_sc_hd__decap_3
XFILLER_81_517 VGND VGND VPWR VPWR sky130_fd_sc_hd__decap_3
XFILLER_93_399 VGND VGND VPWR VPWR sky130_fd_sc_hd__decap_3
XTAP_TAPCELL_ROW_105_1515 VGND VPWR sky130_fd_sc_hd__tapvpwrvgnd_1
XFILLER_34_455 VGND VGND VPWR VPWR sky130_fd_sc_hd__decap_3
XFILLER_61_252 VGND VGND VPWR VPWR sky130_fd_sc_hd__decap_3
XFILLER_21_116 VGND VGND VPWR VPWR sky130_fd_sc_hd__decap_3
XFILLER_61_296 VGND VGND VPWR VPWR sky130_fd_sc_hd__decap_3
XFILLER_21_149 VGND VGND VPWR VPWR sky130_fd_sc_hd__decap_3
XTAP_TAPCELL_ROW_32_634 VGND VPWR sky130_fd_sc_hd__tapvpwrvgnd_1
XTAP_TAPCELL_ROW_60_976 VGND VPWR sky130_fd_sc_hd__tapvpwrvgnd_1
X_4653_ _4648_/Y _4785_/A _4413_/A _4397_/A VGND VGND VPWR VPWR _4653_/Y sky130_fd_sc_hd__a211oi_2
X_7372_ _7372_/CLK _7372_/D _6652_/Y VGND VGND VPWR VPWR _7372_/Q sky130_fd_sc_hd__dfrtp_2
Xhold802 _6977_/Q VGND VGND VPWR VPWR _6977_/D sky130_fd_sc_hd__dlygate4sd3_1
X_3604_ _4938_/A _5072_/A VGND VGND VPWR VPWR _3621_/B sky130_fd_sc_hd__nor2_2
XTAP_TAPCELL_ROW_12_391 VGND VPWR sky130_fd_sc_hd__tapvpwrvgnd_1
Xhold813 _6733_/Q VGND VGND VPWR VPWR _6733_/D sky130_fd_sc_hd__dlygate4sd3_1
Xhold824 _6839_/Q VGND VGND VPWR VPWR _6839_/D sky130_fd_sc_hd__dlygate4sd3_1
Xhold835 _6739_/Q VGND VGND VPWR VPWR _6739_/D sky130_fd_sc_hd__dlygate4sd3_1
Xhold846 _7073_/Q VGND VGND VPWR VPWR _7073_/D sky130_fd_sc_hd__dlygate4sd3_1
Xmax_cap554 _5651_/A VGND VGND VPWR VPWR _5660_/C sky130_fd_sc_hd__clkbuf_2
X_6323_ _6674_/A VGND VGND VPWR VPWR _6323_/Y sky130_fd_sc_hd__inv_2
X_3535_ _3621_/A _3535_/B _4764_/B VGND VGND VPWR VPWR _3536_/B sky130_fd_sc_hd__and3_2
XTAP_TAPCELL_ROW_116_1655 VGND VPWR sky130_fd_sc_hd__tapvpwrvgnd_1
XTAP_TAPCELL_ROW_116_1644 VGND VPWR sky130_fd_sc_hd__tapvpwrvgnd_1
XFILLER_107_38 VGND VGND VPWR VPWR sky130_fd_sc_hd__decap_3
XFILLER_89_617 VGND VGND VPWR VPWR sky130_fd_sc_hd__decap_3
Xhold857 _7066_/Q VGND VGND VPWR VPWR _7066_/D sky130_fd_sc_hd__dlygate4sd3_1
Xhold868 _7102_/Q VGND VGND VPWR VPWR _7102_/D sky130_fd_sc_hd__dlygate4sd3_1
Xhold879 _7062_/Q VGND VGND VPWR VPWR _7062_/D sky130_fd_sc_hd__dlygate4sd3_1
Xmax_cap576 _6288_/A VGND VGND VPWR VPWR _6285_/A sky130_fd_sc_hd__buf_2
Xmax_cap565 _3388_/Y VGND VGND VPWR VPWR _4248_/A sky130_fd_sc_hd__buf_2
X_3466_ _7217_/Q _4331_/A2 _4534_/S _7030_/Q _3465_/X VGND VGND VPWR VPWR _3466_/X
+ sky130_fd_sc_hd__a221o_2
XFILLER_115_287 VGND VGND VPWR VPWR sky130_fd_sc_hd__decap_3
XFILLER_88_138 VGND VGND VPWR VPWR sky130_fd_sc_hd__fill_2
X_5205_ _5205_/A _5217_/B VGND VGND VPWR VPWR _7226_/D sky130_fd_sc_hd__and2_2
XFILLER_57_503 VGND VGND VPWR VPWR sky130_fd_sc_hd__fill_1
XFILLER_69_330 VGND VGND VPWR VPWR sky130_fd_sc_hd__decap_3
XFILLER_69_352 VGND VGND VPWR VPWR sky130_fd_sc_hd__decap_3
XTAP_TAPCELL_ROW_4_304 VGND VPWR sky130_fd_sc_hd__tapvpwrvgnd_1
XFILLER_29_205 VGND VGND VPWR VPWR sky130_fd_sc_hd__decap_3
XFILLER_69_385 VGND VGND VPWR VPWR sky130_fd_sc_hd__decap_3
X_5136_ _5136_/A0 _5135_/X _5136_/S VGND VGND VPWR VPWR _7251_/D sky130_fd_sc_hd__mux2_2
X_5067_ _5648_/A _5067_/B VGND VGND VPWR VPWR _5068_/C sky130_fd_sc_hd__or2_2
X_4018_ _7150_/Q _4428_/B1 _4011_/X _4017_/X VGND VGND VPWR VPWR _4018_/X sky130_fd_sc_hd__a211o_2
XFILLER_16_24 VGND VGND VPWR VPWR sky130_fd_sc_hd__decap_3
XFILLER_16_35 VGND VGND VPWR VPWR sky130_fd_sc_hd__decap_3
XFILLER_25_433 VGND VGND VPWR VPWR sky130_fd_sc_hd__decap_3
XFILLER_13_606 VGND VGND VPWR VPWR sky130_fd_sc_hd__decap_3
XFILLER_13_617 VGND VGND VPWR VPWR sky130_fd_sc_hd__fill_2
XFILLER_52_230 VGND VGND VPWR VPWR sky130_fd_sc_hd__decap_3
XTAP_TAPCELL_ROW_80_1209 VGND VPWR sky130_fd_sc_hd__tapvpwrvgnd_1
XFILLER_40_414 VGND VGND VPWR VPWR sky130_fd_sc_hd__decap_3
XFILLER_80_572 VGND VGND VPWR VPWR sky130_fd_sc_hd__fill_1
XFILLER_40_458 VGND VGND VPWR VPWR sky130_fd_sc_hd__fill_1
XFILLER_32_56 VGND VGND VPWR VPWR sky130_fd_sc_hd__decap_3
XFILLER_20_171 VGND VGND VPWR VPWR sky130_fd_sc_hd__decap_3
XFILLER_106_232 VGND VGND VPWR VPWR sky130_fd_sc_hd__decap_3
XFILLER_106_3 VGND VGND VPWR VPWR sky130_fd_sc_hd__decap_3
XTAP_TAPCELL_ROW_91_1338 VGND VPWR sky130_fd_sc_hd__tapvpwrvgnd_1
XFILLER_0_521 VGND VGND VPWR VPWR sky130_fd_sc_hd__decap_3
XFILLER_106_298 VGND VGND VPWR VPWR sky130_fd_sc_hd__fill_1
XFILLER_79_116 VGND VGND VPWR VPWR sky130_fd_sc_hd__decap_3
XTAP_TAPCELL_ROW_91_1349 VGND VPWR sky130_fd_sc_hd__tapvpwrvgnd_1
XFILLER_79_149 VGND VGND VPWR VPWR sky130_fd_sc_hd__decap_3
XFILLER_94_108 VGND VGND VPWR VPWR sky130_fd_sc_hd__decap_3
XFILLER_0_587 VGND VGND VPWR VPWR sky130_fd_sc_hd__fill_1
XFILLER_102_471 VGND VGND VPWR VPWR sky130_fd_sc_hd__decap_3
XFILLER_48_514 VGND VGND VPWR VPWR sky130_fd_sc_hd__decap_3
XFILLER_48_525 VGND VGND VPWR VPWR sky130_fd_sc_hd__decap_3
XFILLER_48_536 VGND VGND VPWR VPWR sky130_fd_sc_hd__fill_1
XFILLER_57_42 VGND VGND VPWR VPWR sky130_fd_sc_hd__decap_3
XFILLER_88_672 VGND VGND VPWR VPWR sky130_fd_sc_hd__decap_3
XFILLER_57_75 VGND VGND VPWR VPWR sky130_fd_sc_hd__decap_3
XFILLER_75_322 VGND VGND VPWR VPWR sky130_fd_sc_hd__decap_3
XFILLER_75_333 VGND VGND VPWR VPWR sky130_fd_sc_hd__decap_3
XFILLER_75_355 VGND VGND VPWR VPWR sky130_fd_sc_hd__fill_2
XFILLER_113_81 VGND VGND VPWR VPWR sky130_fd_sc_hd__decap_3
XFILLER_28_271 VGND VGND VPWR VPWR sky130_fd_sc_hd__decap_3
XFILLER_73_30 VGND VGND VPWR VPWR sky130_fd_sc_hd__decap_3
XFILLER_16_444 VGND VGND VPWR VPWR sky130_fd_sc_hd__fill_1
XFILLER_43_241 VGND VGND VPWR VPWR sky130_fd_sc_hd__decap_3
XFILLER_16_477 VGND VGND VPWR VPWR sky130_fd_sc_hd__decap_3
XFILLER_71_594 VGND VGND VPWR VPWR sky130_fd_sc_hd__decap_3
XFILLER_92_9 VGND VGND VPWR VPWR sky130_fd_sc_hd__decap_3
XTAP_TAPCELL_ROW_100_1456 VGND VPWR sky130_fd_sc_hd__tapvpwrvgnd_1
XFILLER_7_131 VGND VGND VPWR VPWR sky130_fd_sc_hd__decap_3
XFILLER_7_164 VGND VGND VPWR VPWR sky130_fd_sc_hd__decap_3
XFILLER_8_676 VGND VGND VPWR VPWR sky130_fd_sc_hd__decap_3
X_3320_ _5647_/B VGND VGND VPWR VPWR _3326_/A sky130_fd_sc_hd__inv_2
XFILLER_98_60 VGND VGND VPWR VPWR sky130_fd_sc_hd__fill_1
XFILLER_3_381 VGND VGND VPWR VPWR sky130_fd_sc_hd__decap_3
XFILLER_98_93 VGND VGND VPWR VPWR sky130_fd_sc_hd__decap_3
XFILLER_79_650 VGND VGND VPWR VPWR sky130_fd_sc_hd__decap_3
XFILLER_79_661 VGND VGND VPWR VPWR sky130_fd_sc_hd__decap_3
XFILLER_112_279 VGND VGND VPWR VPWR sky130_fd_sc_hd__decap_3
XFILLER_21_3 VGND VGND VPWR VPWR sky130_fd_sc_hd__decap_3
XFILLER_39_503 VGND VGND VPWR VPWR sky130_fd_sc_hd__fill_1
XFILLER_66_300 VGND VGND VPWR VPWR sky130_fd_sc_hd__fill_2
XFILLER_85_119 VGND VGND VPWR VPWR sky130_fd_sc_hd__decap_3
XTAP_TAPCELL_ROW_111_1585 VGND VPWR sky130_fd_sc_hd__tapvpwrvgnd_1
XFILLER_66_344 VGND VGND VPWR VPWR sky130_fd_sc_hd__decap_3
XFILLER_54_528 VGND VGND VPWR VPWR sky130_fd_sc_hd__decap_3
XFILLER_81_314 VGND VGND VPWR VPWR sky130_fd_sc_hd__fill_2
XFILLER_94_675 VGND VGND VPWR VPWR sky130_fd_sc_hd__decap_3
XFILLER_19_271 VGND VGND VPWR VPWR sky130_fd_sc_hd__decap_3
XFILLER_66_399 VGND VGND VPWR VPWR sky130_fd_sc_hd__decap_3
XFILLER_93_185 VGND VGND VPWR VPWR sky130_fd_sc_hd__fill_1
X_6941_ _7005_/CLK _6941_/D VGND VGND VPWR VPWR _6941_/Q sky130_fd_sc_hd__dfxtp_2
XFILLER_34_230 VGND VGND VPWR VPWR sky130_fd_sc_hd__decap_3
XFILLER_62_550 VGND VGND VPWR VPWR sky130_fd_sc_hd__fill_2
XFILLER_81_358 VGND VGND VPWR VPWR sky130_fd_sc_hd__decap_3
X_6872_ _6975_/CLK _6872_/D VGND VGND VPWR VPWR _6872_/Q sky130_fd_sc_hd__dfxtp_2
XTAP_TAPCELL_ROW_66_1042 VGND VPWR sky130_fd_sc_hd__tapvpwrvgnd_1
XFILLER_34_274 VGND VGND VPWR VPWR sky130_fd_sc_hd__decap_3
XTAP_TAPCELL_ROW_17_461 VGND VPWR sky130_fd_sc_hd__tapvpwrvgnd_1
XTAP_TAPCELL_ROW_17_450 VGND VPWR sky130_fd_sc_hd__tapvpwrvgnd_1
XTAP_TAPCELL_ROW_45_792 VGND VPWR sky130_fd_sc_hd__tapvpwrvgnd_1
X_4705_ _6995_/Q _6996_/Q _4963_/A VGND VGND VPWR VPWR _4931_/A sky130_fd_sc_hd__and3_2
XFILLER_8_80 VGND VGND VPWR VPWR sky130_fd_sc_hd__decap_3
XFILLER_8_91 VGND VGND VPWR VPWR sky130_fd_sc_hd__decap_3
X_4636_ _4186_/A _4636_/B VGND VGND VPWR VPWR _4639_/A sky130_fd_sc_hd__and2b_2
XPHY_EDGE_ROW_62_Left_179 VGND VGND VPWR VPWR sky130_fd_sc_hd__decap_3
X_7355_ clkload4/A _7355_/D _6635_/Y VGND VGND VPWR VPWR _7355_/Q sky130_fd_sc_hd__dfrtp_2
Xhold610 _6752_/Q VGND VGND VPWR VPWR _6752_/D sky130_fd_sc_hd__dlygate4sd3_1
Xhold621 _6780_/Q VGND VGND VPWR VPWR _6780_/D sky130_fd_sc_hd__dlygate4sd3_1
XFILLER_116_574 VGND VGND VPWR VPWR sky130_fd_sc_hd__decap_3
XFILLER_89_414 VGND VGND VPWR VPWR sky130_fd_sc_hd__decap_3
Xhold632 _6840_/Q VGND VGND VPWR VPWR _6840_/D sky130_fd_sc_hd__dlygate4sd3_1
Xhold643 _6735_/Q VGND VGND VPWR VPWR _6735_/D sky130_fd_sc_hd__dlygate4sd3_1
Xhold654 _6784_/Q VGND VGND VPWR VPWR _6784_/D sky130_fd_sc_hd__dlygate4sd3_1
X_6306_ _6525_/A VGND VGND VPWR VPWR _6306_/Y sky130_fd_sc_hd__inv_2
X_4567_ _4567_/A _4567_/B VGND VGND VPWR VPWR _7297_/D sky130_fd_sc_hd__and2_2
XTAP_TAPCELL_ROW_77_1171 VGND VPWR sky130_fd_sc_hd__tapvpwrvgnd_1
XFILLER_89_436 VGND VGND VPWR VPWR sky130_fd_sc_hd__fill_1
X_7286_ clkload7/A _7286_/D _6566_/Y VGND VGND VPWR VPWR _7286_/Q sky130_fd_sc_hd__dfrtp_2
Xhold665 _6876_/Q VGND VGND VPWR VPWR _6876_/D sky130_fd_sc_hd__dlygate4sd3_1
Xhold676 _6737_/Q VGND VGND VPWR VPWR _6737_/D sky130_fd_sc_hd__dlygate4sd3_1
Xhold687 _6881_/Q VGND VGND VPWR VPWR _6881_/D sky130_fd_sc_hd__dlygate4sd3_1
XFILLER_103_235 VGND VGND VPWR VPWR sky130_fd_sc_hd__decap_3
XFILLER_103_257 VGND VGND VPWR VPWR sky130_fd_sc_hd__decap_3
XFILLER_77_609 VGND VGND VPWR VPWR sky130_fd_sc_hd__decap_3
Xhold698 _6807_/Q VGND VGND VPWR VPWR _6807_/D sky130_fd_sc_hd__dlygate4sd3_1
X_3449_ _3449_/A _3449_/B _3449_/C VGND VGND VPWR VPWR _3449_/X sky130_fd_sc_hd__and3_2
XFILLER_85_620 VGND VGND VPWR VPWR sky130_fd_sc_hd__decap_3
XFILLER_94_18 VGND VGND VPWR VPWR sky130_fd_sc_hd__decap_3
XFILLER_111_290 VGND VGND VPWR VPWR sky130_fd_sc_hd__decap_3
XFILLER_57_333 VGND VGND VPWR VPWR sky130_fd_sc_hd__decap_3
XFILLER_84_130 VGND VGND VPWR VPWR sky130_fd_sc_hd__fill_2
XFILLER_85_631 VGND VGND VPWR VPWR sky130_fd_sc_hd__decap_3
XFILLER_94_29 VGND VGND VPWR VPWR sky130_fd_sc_hd__fill_2
X_5119_ _6983_/Q _5670_/B _6984_/Q VGND VGND VPWR VPWR _5120_/B sky130_fd_sc_hd__a21oi_2
XFILLER_17_219 VGND VGND VPWR VPWR sky130_fd_sc_hd__decap_3
XFILLER_27_34 VGND VGND VPWR VPWR sky130_fd_sc_hd__decap_3
XFILLER_57_355 VGND VGND VPWR VPWR sky130_fd_sc_hd__decap_3
XFILLER_84_141 VGND VGND VPWR VPWR sky130_fd_sc_hd__fill_1
XFILLER_85_664 VGND VGND VPWR VPWR sky130_fd_sc_hd__decap_3
XPHY_EDGE_ROW_71_Left_188 VGND VGND VPWR VPWR sky130_fd_sc_hd__decap_3
XFILLER_84_185 VGND VGND VPWR VPWR sky130_fd_sc_hd__fill_1
XFILLER_13_458 VGND VGND VPWR VPWR sky130_fd_sc_hd__fill_1
XFILLER_43_66 VGND VGND VPWR VPWR sky130_fd_sc_hd__decap_3
XFILLER_43_99 VGND VGND VPWR VPWR sky130_fd_sc_hd__decap_3
XPHY_EDGE_ROW_80_Left_197 VGND VGND VPWR VPWR sky130_fd_sc_hd__decap_3
XFILLER_5_602 VGND VGND VPWR VPWR sky130_fd_sc_hd__decap_3
XFILLER_4_112 VGND VGND VPWR VPWR sky130_fd_sc_hd__decap_3
XFILLER_5_646 VGND VGND VPWR VPWR sky130_fd_sc_hd__decap_3
XFILLER_4_156 VGND VGND VPWR VPWR sky130_fd_sc_hd__decap_3
XFILLER_5_679 VGND VGND VPWR VPWR sky130_fd_sc_hd__decap_3
XFILLER_4_27 VGND VGND VPWR VPWR sky130_fd_sc_hd__fill_1
XFILLER_4_38 VGND VGND VPWR VPWR sky130_fd_sc_hd__decap_3
XFILLER_68_63 VGND VGND VPWR VPWR sky130_fd_sc_hd__decap_3
XFILLER_0_340 VGND VGND VPWR VPWR sky130_fd_sc_hd__fill_2
XFILLER_0_362 VGND VGND VPWR VPWR sky130_fd_sc_hd__fill_2
XFILLER_48_300 VGND VGND VPWR VPWR sky130_fd_sc_hd__decap_3
XFILLER_67_108 VGND VGND VPWR VPWR sky130_fd_sc_hd__decap_3
XFILLER_68_85 VGND VGND VPWR VPWR sky130_fd_sc_hd__decap_3
XFILLER_95_428 VGND VGND VPWR VPWR sky130_fd_sc_hd__decap_3
XFILLER_48_322 VGND VGND VPWR VPWR sky130_fd_sc_hd__decap_3
XFILLER_76_631 VGND VGND VPWR VPWR sky130_fd_sc_hd__decap_3
XFILLER_75_163 VGND VGND VPWR VPWR sky130_fd_sc_hd__decap_3
XFILLER_76_675 VGND VGND VPWR VPWR sky130_fd_sc_hd__decap_3
XFILLER_90_100 VGND VGND VPWR VPWR sky130_fd_sc_hd__decap_3
Xplace303 _3605_/Y VGND VGND VPWR VPWR _4811_/C sky130_fd_sc_hd__buf_2
XFILLER_63_358 VGND VGND VPWR VPWR sky130_fd_sc_hd__decap_3
XFILLER_91_667 VGND VGND VPWR VPWR sky130_fd_sc_hd__decap_3
Xplace336 _3377_/X VGND VGND VPWR VPWR _4340_/A2 sky130_fd_sc_hd__buf_2
Xplace325 _3590_/A VGND VGND VPWR VPWR _4460_/A sky130_fd_sc_hd__buf_2
Xplace314 _5274_/S VGND VGND VPWR VPWR _5292_/S sky130_fd_sc_hd__buf_2
XFILLER_44_572 VGND VGND VPWR VPWR sky130_fd_sc_hd__decap_3
Xplace369 _5151_/A VGND VGND VPWR VPWR _5138_/S sky130_fd_sc_hd__buf_2
Xplace358 _4267_/B1 VGND VGND VPWR VPWR _4436_/B1 sky130_fd_sc_hd__buf_2
Xplace347 _3449_/X VGND VGND VPWR VPWR _4337_/B sky130_fd_sc_hd__buf_2
XFILLER_16_285 VGND VGND VPWR VPWR sky130_fd_sc_hd__decap_3
XFILLER_31_211 VGND VGND VPWR VPWR sky130_fd_sc_hd__decap_3
XFILLER_31_244 VGND VGND VPWR VPWR sky130_fd_sc_hd__decap_3
XFILLER_71_391 VGND VGND VPWR VPWR sky130_fd_sc_hd__fill_1
XTAP_TAPCELL_ROW_14_420 VGND VPWR sky130_fd_sc_hd__tapvpwrvgnd_1
XTAP_TAPCELL_ROW_42_751 VGND VPWR sky130_fd_sc_hd__tapvpwrvgnd_1
XFILLER_31_299 VGND VGND VPWR VPWR sky130_fd_sc_hd__fill_2
XFILLER_69_3 VGND VGND VPWR VPWR sky130_fd_sc_hd__decap_3
X_4421_ _7240_/Q _4430_/A2 _4430_/B1 _7176_/Q _4420_/X VGND VGND VPWR VPWR _4421_/X
+ sky130_fd_sc_hd__a221o_2
XTAP_TAPCELL_ROW_113_1603 VGND VPWR sky130_fd_sc_hd__tapvpwrvgnd_1
X_7140_ _7365_/CLK _7140_/D _6420_/Y VGND VGND VPWR VPWR _7140_/Q sky130_fd_sc_hd__dfrtp_2
X_4352_ _7289_/Q _5080_/S _4352_/B1 _7161_/Q _4351_/X VGND VGND VPWR VPWR _4352_/X
+ sky130_fd_sc_hd__a221o_2
XFILLER_113_555 VGND VGND VPWR VPWR sky130_fd_sc_hd__decap_3
XFILLER_4_690 VGND VGND VPWR VPWR sky130_fd_sc_hd__fill_2
X_7071_ _7330_/CLK _7071_/D _6351_/Y VGND VGND VPWR VPWR _7071_/Q sky130_fd_sc_hd__dfrtp_2
X_4283_ _7094_/Q _4321_/A2 _4351_/B1 _7126_/Q VGND VGND VPWR VPWR _4283_/X sky130_fd_sc_hd__a22o_2
X_3303_ _4467_/A _3519_/B _3302_/X VGND VGND VPWR VPWR _6981_/D sky130_fd_sc_hd__o21a_4
XFILLER_113_588 VGND VGND VPWR VPWR sky130_fd_sc_hd__decap_3
XFILLER_58_119 VGND VGND VPWR VPWR sky130_fd_sc_hd__decap_3
XFILLER_98_288 VGND VGND VPWR VPWR sky130_fd_sc_hd__decap_3
XFILLER_100_249 VGND VGND VPWR VPWR sky130_fd_sc_hd__decap_3
XFILLER_79_480 VGND VGND VPWR VPWR sky130_fd_sc_hd__fill_1
XFILLER_27_517 VGND VGND VPWR VPWR sky130_fd_sc_hd__decap_3
XFILLER_67_664 VGND VGND VPWR VPWR sky130_fd_sc_hd__decap_3
XFILLER_39_399 VGND VGND VPWR VPWR sky130_fd_sc_hd__fill_1
XFILLER_54_358 VGND VGND VPWR VPWR sky130_fd_sc_hd__decap_3
XFILLER_82_678 VGND VGND VPWR VPWR sky130_fd_sc_hd__decap_3
X_6924_ _6931_/CLK _6924_/D VGND VGND VPWR VPWR _6924_/Q sky130_fd_sc_hd__dfxtp_2
XFILLER_22_200 VGND VGND VPWR VPWR sky130_fd_sc_hd__decap_3
XFILLER_35_561 VGND VGND VPWR VPWR sky130_fd_sc_hd__fill_2
XFILLER_35_583 VGND VGND VPWR VPWR sky130_fd_sc_hd__decap_3
XFILLER_81_177 VGND VGND VPWR VPWR sky130_fd_sc_hd__decap_3
Xfanout26 _6664_/A VGND VGND VPWR VPWR _6562_/A sky130_fd_sc_hd__buf_2
Xfanout37 fanout38/X VGND VGND VPWR VPWR _6644_/A sky130_fd_sc_hd__buf_2
X_6855_ _6929_/CLK _6855_/D VGND VGND VPWR VPWR _6855_/Q sky130_fd_sc_hd__dfxtp_2
XFILLER_10_417 VGND VGND VPWR VPWR sky130_fd_sc_hd__decap_3
XFILLER_13_14 VGND VGND VPWR VPWR sky130_fd_sc_hd__decap_3
Xfanout48 fanout51/X VGND VGND VPWR VPWR _6385_/A sky130_fd_sc_hd__buf_2
Xfanout59 _6616_/A VGND VGND VPWR VPWR _6675_/A sky130_fd_sc_hd__buf_2
X_6786_ _6975_/CLK _6786_/D VGND VGND VPWR VPWR _6786_/Q sky130_fd_sc_hd__dfxtp_2
XFILLER_13_47 VGND VGND VPWR VPWR sky130_fd_sc_hd__decap_3
XFILLER_22_299 VGND VGND VPWR VPWR sky130_fd_sc_hd__decap_3
XFILLER_50_597 VGND VGND VPWR VPWR sky130_fd_sc_hd__decap_3
X_5737_ _7374_/Q hold956/X _5737_/S VGND VGND VPWR VPWR _6718_/D sky130_fd_sc_hd__mux2_2
XTAP_TAPCELL_ROW_79_1200 VGND VPWR sky130_fd_sc_hd__tapvpwrvgnd_1
XFILLER_89_29 VGND VGND VPWR VPWR sky130_fd_sc_hd__decap_3
X_5668_ _5668_/A _5668_/B VGND VGND VPWR VPWR _6980_/D sky130_fd_sc_hd__or2_2
XTAP_TAPCELL_ROW_20_489 VGND VPWR sky130_fd_sc_hd__tapvpwrvgnd_1
X_4619_ _5086_/A _4619_/B _5101_/B _5073_/A VGND VGND VPWR VPWR _4619_/Y sky130_fd_sc_hd__nor4_2
XFILLER_104_500 VGND VGND VPWR VPWR sky130_fd_sc_hd__decap_3
XFILLER_116_371 VGND VGND VPWR VPWR sky130_fd_sc_hd__decap_3
XFILLER_116_382 VGND VGND VPWR VPWR sky130_fd_sc_hd__decap_3
XFILLER_2_627 VGND VGND VPWR VPWR sky130_fd_sc_hd__decap_3
XFILLER_89_200 VGND VGND VPWR VPWR sky130_fd_sc_hd__decap_3
X_7338_ _7338_/CLK _7338_/D _6618_/Y VGND VGND VPWR VPWR _7338_/Q sky130_fd_sc_hd__dfrtp_2
XFILLER_104_544 VGND VGND VPWR VPWR sky130_fd_sc_hd__decap_3
XFILLER_104_566 VGND VGND VPWR VPWR sky130_fd_sc_hd__decap_3
XFILLER_116_393 VGND VGND VPWR VPWR sky130_fd_sc_hd__decap_3
XFILLER_1_137 VGND VGND VPWR VPWR sky130_fd_sc_hd__decap_3
XFILLER_89_255 VGND VGND VPWR VPWR sky130_fd_sc_hd__decap_3
X_7269_ _7403_/CLK _7269_/D _6549_/Y VGND VGND VPWR VPWR _7269_/Q sky130_fd_sc_hd__dfrtp_2
XFILLER_89_288 VGND VGND VPWR VPWR sky130_fd_sc_hd__decap_3
XFILLER_58_642 VGND VGND VPWR VPWR sky130_fd_sc_hd__fill_2
XFILLER_38_88 VGND VGND VPWR VPWR sky130_fd_sc_hd__fill_1
XFILLER_57_141 VGND VGND VPWR VPWR sky130_fd_sc_hd__decap_3
XFILLER_58_675 VGND VGND VPWR VPWR sky130_fd_sc_hd__decap_3
XFILLER_85_461 VGND VGND VPWR VPWR sky130_fd_sc_hd__decap_3
Xhold1140 _7326_/Q VGND VGND VPWR VPWR _4507_/A0 sky130_fd_sc_hd__dlygate4sd3_1
Xhold1151 _7300_/Q VGND VGND VPWR VPWR _4561_/A sky130_fd_sc_hd__dlygate4sd3_1
XFILLER_45_314 VGND VGND VPWR VPWR sky130_fd_sc_hd__decap_3
XFILLER_73_623 VGND VGND VPWR VPWR sky130_fd_sc_hd__decap_3
XFILLER_85_494 VGND VGND VPWR VPWR sky130_fd_sc_hd__decap_3
Xhold1162 _7210_/Q VGND VGND VPWR VPWR _5240_/B2 sky130_fd_sc_hd__dlygate4sd3_1
Xhold1173 _7152_/Q VGND VGND VPWR VPWR _5358_/A0 sky130_fd_sc_hd__dlygate4sd3_1
Xhold1184 _7128_/Q VGND VGND VPWR VPWR _5411_/A0 sky130_fd_sc_hd__dlygate4sd3_1
XFILLER_45_358 VGND VGND VPWR VPWR sky130_fd_sc_hd__fill_2
XFILLER_54_21 VGND VGND VPWR VPWR sky130_fd_sc_hd__decap_3
XFILLER_54_32 VGND VGND VPWR VPWR sky130_fd_sc_hd__decap_3
XFILLER_72_144 VGND VGND VPWR VPWR sky130_fd_sc_hd__decap_3
Xhold1195 _7119_/Q VGND VGND VPWR VPWR _5429_/A0 sky130_fd_sc_hd__dlygate4sd3_1
XFILLER_54_65 VGND VGND VPWR VPWR sky130_fd_sc_hd__decap_3
XFILLER_72_188 VGND VGND VPWR VPWR sky130_fd_sc_hd__decap_3
XTAP_TAPCELL_ROW_28_589 VGND VPWR sky130_fd_sc_hd__tapvpwrvgnd_1
XFILLER_53_391 VGND VGND VPWR VPWR sky130_fd_sc_hd__fill_1
XPHY_EDGE_ROW_109_Left_226 VGND VGND VPWR VPWR sky130_fd_sc_hd__decap_3
XFILLER_110_71 VGND VGND VPWR VPWR sky130_fd_sc_hd__decap_3
XFILLER_13_255 VGND VGND VPWR VPWR sky130_fd_sc_hd__decap_3
XFILLER_41_564 VGND VGND VPWR VPWR sky130_fd_sc_hd__fill_2
XFILLER_5_410 VGND VGND VPWR VPWR sky130_fd_sc_hd__decap_3
Xclkload18 _6931_/CLK VGND VGND VPWR VPWR clkload18/X sky130_fd_sc_hd__clkbuf_1
Xclkload29 _7365_/CLK VGND VGND VPWR VPWR clkload29/Y sky130_fd_sc_hd__clkinv_2
XFILLER_55_9 VGND VGND VPWR VPWR sky130_fd_sc_hd__decap_3
XFILLER_107_360 VGND VGND VPWR VPWR sky130_fd_sc_hd__decap_3
XFILLER_107_371 VGND VGND VPWR VPWR sky130_fd_sc_hd__decap_3
XFILLER_79_84 VGND VGND VPWR VPWR sky130_fd_sc_hd__decap_3
XFILLER_1_671 VGND VGND VPWR VPWR sky130_fd_sc_hd__fill_1
XFILLER_110_536 VGND VGND VPWR VPWR sky130_fd_sc_hd__decap_3
XFILLER_1_682 VGND VGND VPWR VPWR sky130_fd_sc_hd__fill_2
XFILLER_49_620 VGND VGND VPWR VPWR sky130_fd_sc_hd__decap_3
XFILLER_95_225 VGND VGND VPWR VPWR sky130_fd_sc_hd__decap_3
XFILLER_95_50 VGND VGND VPWR VPWR sky130_fd_sc_hd__decap_3
XFILLER_0_192 VGND VGND VPWR VPWR sky130_fd_sc_hd__decap_3
XFILLER_48_141 VGND VGND VPWR VPWR sky130_fd_sc_hd__decap_3
XFILLER_49_653 VGND VGND VPWR VPWR sky130_fd_sc_hd__decap_3
XFILLER_76_450 VGND VGND VPWR VPWR sky130_fd_sc_hd__decap_3
XFILLER_83_409 VGND VGND VPWR VPWR sky130_fd_sc_hd__fill_1
XFILLER_95_72 VGND VGND VPWR VPWR sky130_fd_sc_hd__decap_3
XFILLER_48_174 VGND VGND VPWR VPWR sky130_fd_sc_hd__decap_3
XFILLER_63_111 VGND VGND VPWR VPWR sky130_fd_sc_hd__fill_1
XFILLER_64_634 VGND VGND VPWR VPWR sky130_fd_sc_hd__decap_3
XFILLER_64_645 VGND VGND VPWR VPWR sky130_fd_sc_hd__decap_3
XFILLER_76_472 VGND VGND VPWR VPWR sky130_fd_sc_hd__decap_3
XFILLER_76_494 VGND VGND VPWR VPWR sky130_fd_sc_hd__fill_2
XTAP_TAPCELL_ROW_47_821 VGND VPWR sky130_fd_sc_hd__tapvpwrvgnd_1
XTAP_TAPCELL_ROW_47_810 VGND VPWR sky130_fd_sc_hd__tapvpwrvgnd_1
XFILLER_64_678 VGND VGND VPWR VPWR sky130_fd_sc_hd__decap_3
XFILLER_51_317 VGND VGND VPWR VPWR sky130_fd_sc_hd__decap_3
X_4970_ _5114_/A _4950_/B _4967_/B _5033_/B2 VGND VGND VPWR VPWR _4970_/X sky130_fd_sc_hd__a22o_2
X_3921_ _6914_/Q _3926_/A2 _3925_/A2 _6688_/Q VGND VGND VPWR VPWR _3921_/X sky130_fd_sc_hd__a22o_2
XTAP_TAPCELL_ROW_63_1012 VGND VPWR sky130_fd_sc_hd__tapvpwrvgnd_1
XFILLER_32_553 VGND VGND VPWR VPWR sky130_fd_sc_hd__decap_3
X_6640_ _6640_/A VGND VGND VPWR VPWR _6640_/Y sky130_fd_sc_hd__inv_2
X_3852_ _6748_/Q _3906_/A2 _3917_/B1 _6742_/Q VGND VGND VPWR VPWR _3852_/X sky130_fd_sc_hd__a22o_2
X_6571_ _6632_/A VGND VGND VPWR VPWR _6571_/Y sky130_fd_sc_hd__inv_2
X_3783_ _6812_/Q _3853_/B1 _3665_/X _6822_/Q _3782_/X VGND VGND VPWR VPWR _3783_/X
+ sky130_fd_sc_hd__a221o_2
XFILLER_8_292 VGND VGND VPWR VPWR sky130_fd_sc_hd__decap_3
Xoutput501 _5161_/A VGND VGND VPWR VPWR instruction_out[18] sky130_fd_sc_hd__clkdlybuf4s25_1
Xoutput545 _6980_/Q VGND VGND VPWR VPWR pc_out[3] sky130_fd_sc_hd__clkdlybuf4s25_1
Xoutput534 _6999_/Q VGND VGND VPWR VPWR pc_out[22] sky130_fd_sc_hd__clkdlybuf4s25_1
Xoutput523 _6989_/Q VGND VGND VPWR VPWR pc_out[12] sky130_fd_sc_hd__clkdlybuf4s25_1
Xoutput512 _7412_/X VGND VGND VPWR VPWR instruction_out[30] sky130_fd_sc_hd__clkdlybuf4s25_1
X_4404_ _7306_/Q _4865_/S _4434_/A2 _7114_/Q VGND VGND VPWR VPWR _4404_/X sky130_fd_sc_hd__a22o_2
XFILLER_5_81 VGND VGND VPWR VPWR sky130_fd_sc_hd__decap_3
X_7123_ clkload6/A _7123_/D _6403_/Y VGND VGND VPWR VPWR _7123_/Q sky130_fd_sc_hd__dfrtp_2
X_4335_ _7287_/Q _5136_/S _3417_/X _7095_/Q VGND VGND VPWR VPWR _4336_/C sky130_fd_sc_hd__a22o_2
XTAP_TAPCELL_ROW_74_1141 VGND VPWR sky130_fd_sc_hd__tapvpwrvgnd_1
XFILLER_101_514 VGND VGND VPWR VPWR sky130_fd_sc_hd__decap_3
XFILLER_113_352 VGND VGND VPWR VPWR sky130_fd_sc_hd__decap_3
XFILLER_86_214 VGND VGND VPWR VPWR sky130_fd_sc_hd__decap_3
XFILLER_99_575 VGND VGND VPWR VPWR sky130_fd_sc_hd__decap_3
XFILLER_113_385 VGND VGND VPWR VPWR sky130_fd_sc_hd__decap_3
XFILLER_115_38 VGND VGND VPWR VPWR sky130_fd_sc_hd__decap_3
XFILLER_59_439 VGND VGND VPWR VPWR sky130_fd_sc_hd__decap_3
X_7054_ _7341_/CLK _7054_/D _6334_/Y VGND VGND VPWR VPWR _7054_/Q sky130_fd_sc_hd__dfrtp_2
X_4266_ _7294_/Q _5126_/S _4321_/A2 _7102_/Q VGND VGND VPWR VPWR _4271_/A sky130_fd_sc_hd__a22o_2
XFILLER_39_152 VGND VGND VPWR VPWR sky130_fd_sc_hd__decap_3
X_4197_ _7199_/Q _3962_/S _4505_/S _7044_/Q _4196_/X VGND VGND VPWR VPWR _4197_/X
+ sky130_fd_sc_hd__a221o_2
XFILLER_54_100 VGND VGND VPWR VPWR sky130_fd_sc_hd__decap_3
XFILLER_55_612 VGND VGND VPWR VPWR sky130_fd_sc_hd__decap_3
XFILLER_55_623 VGND VGND VPWR VPWR sky130_fd_sc_hd__decap_3
XFILLER_67_472 VGND VGND VPWR VPWR sky130_fd_sc_hd__fill_1
XFILLER_94_280 VGND VGND VPWR VPWR sky130_fd_sc_hd__decap_3
XFILLER_54_133 VGND VGND VPWR VPWR sky130_fd_sc_hd__fill_2
XFILLER_54_144 VGND VGND VPWR VPWR sky130_fd_sc_hd__decap_3
XFILLER_55_656 VGND VGND VPWR VPWR sky130_fd_sc_hd__decap_3
XFILLER_54_177 VGND VGND VPWR VPWR sky130_fd_sc_hd__decap_3
XFILLER_82_486 VGND VGND VPWR VPWR sky130_fd_sc_hd__decap_3
X_6907_ _6964_/CLK _6907_/D VGND VGND VPWR VPWR _6907_/Q sky130_fd_sc_hd__dfxtp_2
XTAP_TAPCELL_ROW_85_1270 VGND VPWR sky130_fd_sc_hd__tapvpwrvgnd_1
XTAP_TAPCELL_ROW_25_548 VGND VPWR sky130_fd_sc_hd__tapvpwrvgnd_1
XFILLER_24_35 VGND VGND VPWR VPWR sky130_fd_sc_hd__decap_3
X_6838_ _6978_/CLK _6838_/D VGND VGND VPWR VPWR _6838_/Q sky130_fd_sc_hd__dfxtp_2
XFILLER_10_225 VGND VGND VPWR VPWR sky130_fd_sc_hd__decap_3
XFILLER_50_383 VGND VGND VPWR VPWR sky130_fd_sc_hd__fill_1
X_6769_ _6966_/CLK _6769_/D VGND VGND VPWR VPWR _6769_/Q sky130_fd_sc_hd__dfxtp_2
XFILLER_109_647 VGND VGND VPWR VPWR sky130_fd_sc_hd__decap_3
XFILLER_2_413 VGND VGND VPWR VPWR sky130_fd_sc_hd__decap_3
XFILLER_116_190 VGND VGND VPWR VPWR sky130_fd_sc_hd__decap_3
XFILLER_2_424 VGND VGND VPWR VPWR sky130_fd_sc_hd__decap_3
XFILLER_2_457 VGND VGND VPWR VPWR sky130_fd_sc_hd__fill_2
XFILLER_49_43 VGND VGND VPWR VPWR sky130_fd_sc_hd__decap_3
XFILLER_77_225 VGND VGND VPWR VPWR sky130_fd_sc_hd__decap_3
XFILLER_1_17 VGND VGND VPWR VPWR sky130_fd_sc_hd__decap_3
XFILLER_92_206 VGND VGND VPWR VPWR sky130_fd_sc_hd__decap_3
XFILLER_105_93 VGND VGND VPWR VPWR sky130_fd_sc_hd__decap_3
XFILLER_46_612 VGND VGND VPWR VPWR sky130_fd_sc_hd__decap_3
XFILLER_18_336 VGND VGND VPWR VPWR sky130_fd_sc_hd__decap_3
XFILLER_45_144 VGND VGND VPWR VPWR sky130_fd_sc_hd__decap_3
XFILLER_46_645 VGND VGND VPWR VPWR sky130_fd_sc_hd__decap_3
XFILLER_73_442 VGND VGND VPWR VPWR sky130_fd_sc_hd__decap_3
XFILLER_45_155 VGND VGND VPWR VPWR sky130_fd_sc_hd__decap_3
XFILLER_46_678 VGND VGND VPWR VPWR sky130_fd_sc_hd__decap_3
XFILLER_61_626 VGND VGND VPWR VPWR sky130_fd_sc_hd__decap_3
XFILLER_65_86 VGND VGND VPWR VPWR sky130_fd_sc_hd__decap_3
XFILLER_73_464 VGND VGND VPWR VPWR sky130_fd_sc_hd__decap_3
XFILLER_61_659 VGND VGND VPWR VPWR sky130_fd_sc_hd__decap_3
XFILLER_14_542 VGND VGND VPWR VPWR sky130_fd_sc_hd__decap_3
XFILLER_60_147 VGND VGND VPWR VPWR sky130_fd_sc_hd__decap_3
XFILLER_81_30 VGND VGND VPWR VPWR sky130_fd_sc_hd__decap_3
XFILLER_81_63 VGND VGND VPWR VPWR sky130_fd_sc_hd__decap_3
XFILLER_14_586 VGND VGND VPWR VPWR sky130_fd_sc_hd__fill_2
XFILLER_41_361 VGND VGND VPWR VPWR sky130_fd_sc_hd__decap_3
XFILLER_81_96 VGND VGND VPWR VPWR sky130_fd_sc_hd__fill_2
XTAP_TAPCELL_ROW_99_1439 VGND VPWR sky130_fd_sc_hd__tapvpwrvgnd_1
XFILLER_115_606 VGND VGND VPWR VPWR sky130_fd_sc_hd__decap_3
XFILLER_115_617 VGND VGND VPWR VPWR sky130_fd_sc_hd__decap_3
XPHY_EDGE_ROW_116_Right_116 VGND VGND VPWR VPWR sky130_fd_sc_hd__decap_3
XFILLER_114_127 VGND VGND VPWR VPWR sky130_fd_sc_hd__decap_3
XFILLER_53_6 VGND VGND VPWR VPWR sky130_fd_sc_hd__decap_3
XFILLER_107_190 VGND VGND VPWR VPWR sky130_fd_sc_hd__decap_3
XFILLER_5_284 VGND VGND VPWR VPWR sky130_fd_sc_hd__decap_3
XFILLER_68_203 VGND VGND VPWR VPWR sky130_fd_sc_hd__decap_3
XFILLER_68_225 VGND VGND VPWR VPWR sky130_fd_sc_hd__decap_3
X_4120_ _7300_/Q _4879_/S _4351_/A2 _7108_/Q VGND VGND VPWR VPWR _4120_/X sky130_fd_sc_hd__a22o_2
XFILLER_96_567 VGND VGND VPWR VPWR sky130_fd_sc_hd__decap_3
XFILLER_96_589 VGND VGND VPWR VPWR sky130_fd_sc_hd__decap_3
XFILLER_49_472 VGND VGND VPWR VPWR sky130_fd_sc_hd__decap_3
XFILLER_49_494 VGND VGND VPWR VPWR sky130_fd_sc_hd__decap_3
XFILLER_36_111 VGND VGND VPWR VPWR sky130_fd_sc_hd__decap_3
XTAP_TAPCELL_ROW_108_1546 VGND VPWR sky130_fd_sc_hd__tapvpwrvgnd_1
XFILLER_24_306 VGND VGND VPWR VPWR sky130_fd_sc_hd__fill_2
XFILLER_36_166 VGND VGND VPWR VPWR sky130_fd_sc_hd__decap_3
XFILLER_51_103 VGND VGND VPWR VPWR sky130_fd_sc_hd__decap_3
XFILLER_52_604 VGND VGND VPWR VPWR sky130_fd_sc_hd__decap_3
XFILLER_64_475 VGND VGND VPWR VPWR sky130_fd_sc_hd__fill_1
XFILLER_101_29 VGND VGND VPWR VPWR sky130_fd_sc_hd__decap_3
XFILLER_51_125 VGND VGND VPWR VPWR sky130_fd_sc_hd__decap_3
XFILLER_52_637 VGND VGND VPWR VPWR sky130_fd_sc_hd__decap_3
XFILLER_52_648 VGND VGND VPWR VPWR sky130_fd_sc_hd__decap_3
X_4953_ _4186_/Y _4381_/A _4969_/C _4814_/A VGND VGND VPWR VPWR _4953_/Y sky130_fd_sc_hd__a31oi_2
XFILLER_51_147 VGND VGND VPWR VPWR sky130_fd_sc_hd__fill_2
XFILLER_51_169 VGND VGND VPWR VPWR sky130_fd_sc_hd__fill_1
X_3904_ _5138_/S _3904_/B VGND VGND VPWR VPWR _3904_/Y sky130_fd_sc_hd__nand2_2
XFILLER_20_512 VGND VGND VPWR VPWR sky130_fd_sc_hd__fill_2
XFILLER_32_361 VGND VGND VPWR VPWR sky130_fd_sc_hd__decap_3
XFILLER_60_681 VGND VGND VPWR VPWR sky130_fd_sc_hd__decap_3
X_6623_ _6672_/A VGND VGND VPWR VPWR _6623_/Y sky130_fd_sc_hd__inv_2
X_4884_ _4884_/A _4904_/B VGND VGND VPWR VPWR _4884_/X sky130_fd_sc_hd__or2_2
XTAP_TAPCELL_ROW_50_849 VGND VPWR sky130_fd_sc_hd__tapvpwrvgnd_1
XTAP_TAPCELL_ROW_22_518 VGND VPWR sky130_fd_sc_hd__tapvpwrvgnd_1
XFILLER_20_556 VGND VGND VPWR VPWR sky130_fd_sc_hd__decap_3
X_3835_ _6725_/Q _3886_/A2 _3886_/B1 _6975_/Q VGND VGND VPWR VPWR _3835_/X sky130_fd_sc_hd__a22o_2
X_6554_ _6584_/A VGND VGND VPWR VPWR _6554_/Y sky130_fd_sc_hd__inv_2
X_3766_ hold982/X _4466_/A _4927_/B VGND VGND VPWR VPWR _7394_/D sky130_fd_sc_hd__a21o_2
X_6485_ _6616_/A VGND VGND VPWR VPWR _6485_/Y sky130_fd_sc_hd__inv_2
XFILLER_105_116 VGND VGND VPWR VPWR sky130_fd_sc_hd__decap_3
XFILLER_106_628 VGND VGND VPWR VPWR sky130_fd_sc_hd__decap_3
XFILLER_10_15 VGND VGND VPWR VPWR sky130_fd_sc_hd__decap_3
X_3697_ _3682_/A _3696_/X _3709_/B1 VGND VGND VPWR VPWR _3697_/Y sky130_fd_sc_hd__a21oi_2
XFILLER_10_59 VGND VGND VPWR VPWR sky130_fd_sc_hd__decap_3
XFILLER_114_672 VGND VGND VPWR VPWR sky130_fd_sc_hd__decap_3
X_5367_ _5367_/A0 _4734_/X _5383_/S VGND VGND VPWR VPWR _7149_/D sky130_fd_sc_hd__mux2_2
XFILLER_99_372 VGND VGND VPWR VPWR sky130_fd_sc_hd__decap_3
XFILLER_101_311 VGND VGND VPWR VPWR sky130_fd_sc_hd__decap_3
XFILLER_59_214 VGND VGND VPWR VPWR sky130_fd_sc_hd__decap_3
X_7106_ _7266_/CLK _7106_/D _6386_/Y VGND VGND VPWR VPWR _7106_/Q sky130_fd_sc_hd__dfrtp_2
X_5298_ _5298_/A0 _4734_/X _5323_/S VGND VGND VPWR VPWR _7181_/D sky130_fd_sc_hd__mux2_2
X_4318_ _7290_/Q _4517_/S _3366_/X _7162_/Q _4317_/X VGND VGND VPWR VPWR _4318_/X
+ sky130_fd_sc_hd__a221o_2
XFILLER_101_366 VGND VGND VPWR VPWR sky130_fd_sc_hd__decap_3
XFILLER_113_193 VGND VGND VPWR VPWR sky130_fd_sc_hd__decap_3
XFILLER_19_35 VGND VGND VPWR VPWR sky130_fd_sc_hd__decap_3
XFILLER_59_258 VGND VGND VPWR VPWR sky130_fd_sc_hd__decap_3
XFILLER_87_567 VGND VGND VPWR VPWR sky130_fd_sc_hd__fill_1
X_7037_ clkload4/A _7037_/D _6317_/Y VGND VGND VPWR VPWR _7037_/Q sky130_fd_sc_hd__dfrtp_2
X_4249_ _7069_/Q _4265_/B _4460_/A VGND VGND VPWR VPWR _4626_/C sky130_fd_sc_hd__o21a_2
XFILLER_101_399 VGND VGND VPWR VPWR sky130_fd_sc_hd__decap_3
XFILLER_19_79 VGND VGND VPWR VPWR sky130_fd_sc_hd__fill_2
XTAP_TAPCELL_ROW_58_949 VGND VPWR sky130_fd_sc_hd__tapvpwrvgnd_1
XFILLER_27_144 VGND VGND VPWR VPWR sky130_fd_sc_hd__decap_3
XFILLER_28_645 VGND VGND VPWR VPWR sky130_fd_sc_hd__decap_3
XFILLER_15_317 VGND VGND VPWR VPWR sky130_fd_sc_hd__decap_3
XFILLER_35_23 VGND VGND VPWR VPWR sky130_fd_sc_hd__decap_3
XFILLER_43_626 VGND VGND VPWR VPWR sky130_fd_sc_hd__decap_3
XFILLER_55_475 VGND VGND VPWR VPWR sky130_fd_sc_hd__decap_3
XFILLER_70_412 VGND VGND VPWR VPWR sky130_fd_sc_hd__decap_3
XTAP_TAPCELL_ROW_2_276 VGND VPWR sky130_fd_sc_hd__tapvpwrvgnd_1
XFILLER_43_659 VGND VGND VPWR VPWR sky130_fd_sc_hd__decap_3
XFILLER_70_445 VGND VGND VPWR VPWR sky130_fd_sc_hd__decap_3
XFILLER_30_309 VGND VGND VPWR VPWR sky130_fd_sc_hd__decap_3
XFILLER_42_147 VGND VGND VPWR VPWR sky130_fd_sc_hd__decap_3
XFILLER_70_489 VGND VGND VPWR VPWR sky130_fd_sc_hd__decap_3
XFILLER_50_180 VGND VGND VPWR VPWR sky130_fd_sc_hd__decap_3
XFILLER_51_33 VGND VGND VPWR VPWR sky130_fd_sc_hd__decap_3
XFILLER_109_411 VGND VGND VPWR VPWR sky130_fd_sc_hd__decap_3
XFILLER_51_88 VGND VGND VPWR VPWR sky130_fd_sc_hd__decap_3
XFILLER_7_538 VGND VGND VPWR VPWR sky130_fd_sc_hd__decap_3
XFILLER_109_455 VGND VGND VPWR VPWR sky130_fd_sc_hd__decap_3
XFILLER_105_661 VGND VGND VPWR VPWR sky130_fd_sc_hd__decap_3
XFILLER_111_108 VGND VGND VPWR VPWR sky130_fd_sc_hd__decap_3
XFILLER_2_265 VGND VGND VPWR VPWR sky130_fd_sc_hd__decap_3
XFILLER_78_501 VGND VGND VPWR VPWR sky130_fd_sc_hd__decap_3
XFILLER_104_182 VGND VGND VPWR VPWR sky130_fd_sc_hd__decap_3
XFILLER_111_119 VGND VGND VPWR VPWR sky130_fd_sc_hd__decap_3
XFILLER_2_276 VGND VGND VPWR VPWR sky130_fd_sc_hd__decap_3
XFILLER_2_298 VGND VGND VPWR VPWR sky130_fd_sc_hd__fill_1
XFILLER_104_193 VGND VGND VPWR VPWR sky130_fd_sc_hd__decap_3
XFILLER_18_100 VGND VGND VPWR VPWR sky130_fd_sc_hd__decap_3
XFILLER_18_9 VGND VGND VPWR VPWR sky130_fd_sc_hd__decap_3
XFILLER_65_217 VGND VGND VPWR VPWR sky130_fd_sc_hd__decap_3
XFILLER_65_228 VGND VGND VPWR VPWR sky130_fd_sc_hd__decap_3
XFILLER_76_85 VGND VGND VPWR VPWR sky130_fd_sc_hd__decap_3
XFILLER_78_589 VGND VGND VPWR VPWR sky130_fd_sc_hd__decap_3
XFILLER_93_537 VGND VGND VPWR VPWR sky130_fd_sc_hd__decap_3
XFILLER_18_133 VGND VGND VPWR VPWR sky130_fd_sc_hd__decap_3
XFILLER_46_431 VGND VGND VPWR VPWR sky130_fd_sc_hd__decap_3
XFILLER_18_144 VGND VGND VPWR VPWR sky130_fd_sc_hd__decap_3
XFILLER_18_166 VGND VGND VPWR VPWR sky130_fd_sc_hd__decap_3
XFILLER_46_464 VGND VGND VPWR VPWR sky130_fd_sc_hd__decap_3
XFILLER_46_486 VGND VGND VPWR VPWR sky130_fd_sc_hd__decap_3
XFILLER_73_261 VGND VGND VPWR VPWR sky130_fd_sc_hd__fill_2
XFILLER_61_423 VGND VGND VPWR VPWR sky130_fd_sc_hd__decap_3
XFILLER_73_272 VGND VGND VPWR VPWR sky130_fd_sc_hd__decap_3
XFILLER_33_147 VGND VGND VPWR VPWR sky130_fd_sc_hd__decap_3
XFILLER_33_169 VGND VGND VPWR VPWR sky130_fd_sc_hd__decap_3
XFILLER_42_681 VGND VGND VPWR VPWR sky130_fd_sc_hd__decap_3
XTAP_TAPCELL_ROW_103_1487 VGND VPWR sky130_fd_sc_hd__tapvpwrvgnd_1
X_3620_ _3620_/A _4292_/B _3620_/C VGND VGND VPWR VPWR _3620_/X sky130_fd_sc_hd__or3_4
X_3551_ _3508_/A _3547_/Y _3550_/X VGND VGND VPWR VPWR _3551_/X sky130_fd_sc_hd__a21o_2
XFILLER_51_3 VGND VGND VPWR VPWR sky130_fd_sc_hd__decap_3
X_6270_ _6553_/A VGND VGND VPWR VPWR _6270_/Y sky130_fd_sc_hd__inv_2
X_3482_ _3482_/A _3482_/B _3482_/C VGND VGND VPWR VPWR _3482_/Y sky130_fd_sc_hd__nor3_2
XFILLER_88_309 VGND VGND VPWR VPWR sky130_fd_sc_hd__decap_3
X_5221_ _5221_/A _5225_/B VGND VGND VPWR VPWR _7218_/D sky130_fd_sc_hd__and2_2
XTAP_TAPCELL_ROW_71_1100 VGND VPWR sky130_fd_sc_hd__tapvpwrvgnd_1
XFILLER_111_620 VGND VGND VPWR VPWR sky130_fd_sc_hd__decap_3
X_5152_ _7009_/Q _5152_/B VGND VGND VPWR VPWR _5152_/Y sky130_fd_sc_hd__nand2_2
XFILLER_111_653 VGND VGND VPWR VPWR sky130_fd_sc_hd__decap_3
XFILLER_69_556 VGND VGND VPWR VPWR sky130_fd_sc_hd__decap_3
XFILLER_96_353 VGND VGND VPWR VPWR sky130_fd_sc_hd__decap_3
X_4103_ _7365_/Q _4272_/B _4267_/B1 _7173_/Q VGND VGND VPWR VPWR _4103_/X sky130_fd_sc_hd__a22o_2
XFILLER_110_174 VGND VGND VPWR VPWR sky130_fd_sc_hd__decap_3
XFILLER_2_71 VGND VGND VPWR VPWR sky130_fd_sc_hd__decap_3
X_5083_ _5086_/A _4343_/X VGND VGND VPWR VPWR _5083_/X sky130_fd_sc_hd__or2b_2
X_4034_ _7150_/Q _4434_/B1 _4032_/X _4033_/X VGND VGND VPWR VPWR _4034_/X sky130_fd_sc_hd__a211o_2
XTAP_TAPCELL_ROW_55_908 VGND VPWR sky130_fd_sc_hd__tapvpwrvgnd_1
XFILLER_112_17 VGND VGND VPWR VPWR sky130_fd_sc_hd__decap_3
XFILLER_37_464 VGND VGND VPWR VPWR sky130_fd_sc_hd__decap_3
XFILLER_64_250 VGND VGND VPWR VPWR sky130_fd_sc_hd__fill_2
XFILLER_24_125 VGND VGND VPWR VPWR sky130_fd_sc_hd__decap_3
XFILLER_92_592 VGND VGND VPWR VPWR sky130_fd_sc_hd__fill_2
XTAP_TAPCELL_ROW_69_1084 VGND VPWR sky130_fd_sc_hd__tapvpwrvgnd_1
XFILLER_12_309 VGND VGND VPWR VPWR sky130_fd_sc_hd__decap_3
XFILLER_24_147 VGND VGND VPWR VPWR sky130_fd_sc_hd__decap_3
XTAP_TAPCELL_ROW_82_1240 VGND VPWR sky130_fd_sc_hd__tapvpwrvgnd_1
XFILLER_33_670 VGND VGND VPWR VPWR sky130_fd_sc_hd__fill_2
XFILLER_52_489 VGND VGND VPWR VPWR sky130_fd_sc_hd__fill_1
X_4936_ _4936_/A _4936_/B VGND VGND VPWR VPWR _4936_/Y sky130_fd_sc_hd__xnor2_2
XTAP_TAPCELL_ROW_35_676 VGND VPWR sky130_fd_sc_hd__tapvpwrvgnd_1
X_4867_ _6998_/Q _4912_/A VGND VGND VPWR VPWR _4882_/A sky130_fd_sc_hd__nand2_2
X_6606_ _6606_/A VGND VGND VPWR VPWR _6606_/Y sky130_fd_sc_hd__inv_2
X_3818_ hold984/X _3833_/S _3817_/X VGND VGND VPWR VPWR _7390_/D sky130_fd_sc_hd__o21a_2
X_6537_ _6540_/A VGND VGND VPWR VPWR _6537_/Y sky130_fd_sc_hd__inv_2
X_4798_ _4811_/C _4795_/X _4796_/Y _4797_/X VGND VGND VPWR VPWR _5656_/A sky130_fd_sc_hd__a211o_2
XFILLER_106_403 VGND VGND VPWR VPWR sky130_fd_sc_hd__decap_3
X_3749_ _3726_/X _3734_/X _3748_/X _3896_/B1 VGND VGND VPWR VPWR _3749_/Y sky130_fd_sc_hd__o31ai_2
XFILLER_97_18 VGND VGND VPWR VPWR sky130_fd_sc_hd__decap_3
X_6468_ _6539_/A VGND VGND VPWR VPWR _6468_/Y sky130_fd_sc_hd__inv_2
X_6399_ _6562_/A VGND VGND VPWR VPWR _6399_/Y sky130_fd_sc_hd__inv_2
X_5419_ _5419_/A0 _5131_/X _5429_/S VGND VGND VPWR VPWR _7124_/D sky130_fd_sc_hd__mux2_2
XFILLER_114_480 VGND VGND VPWR VPWR sky130_fd_sc_hd__decap_3
XTAP_TAPCELL_ROW_7_335 VGND VPWR sky130_fd_sc_hd__tapvpwrvgnd_1
XFILLER_87_342 VGND VGND VPWR VPWR sky130_fd_sc_hd__decap_3
XFILLER_87_353 VGND VGND VPWR VPWR sky130_fd_sc_hd__decap_3
XFILLER_102_675 VGND VGND VPWR VPWR sky130_fd_sc_hd__decap_3
XFILLER_47_206 VGND VGND VPWR VPWR sky130_fd_sc_hd__decap_3
XFILLER_47_217 VGND VGND VPWR VPWR sky130_fd_sc_hd__fill_2
XFILLER_75_526 VGND VGND VPWR VPWR sky130_fd_sc_hd__decap_3
XFILLER_47_239 VGND VGND VPWR VPWR sky130_fd_sc_hd__fill_2
XFILLER_75_559 VGND VGND VPWR VPWR sky130_fd_sc_hd__fill_1
XFILLER_16_615 VGND VGND VPWR VPWR sky130_fd_sc_hd__decap_3
XFILLER_28_475 VGND VGND VPWR VPWR sky130_fd_sc_hd__fill_1
XFILLER_62_209 VGND VGND VPWR VPWR sky130_fd_sc_hd__decap_3
XFILLER_28_497 VGND VGND VPWR VPWR sky130_fd_sc_hd__fill_1
XFILLER_46_88 VGND VGND VPWR VPWR sky130_fd_sc_hd__decap_3
XFILLER_55_272 VGND VGND VPWR VPWR sky130_fd_sc_hd__fill_1
XFILLER_102_61 VGND VGND VPWR VPWR sky130_fd_sc_hd__decap_3
XFILLER_15_147 VGND VGND VPWR VPWR sky130_fd_sc_hd__decap_3
XFILLER_15_169 VGND VGND VPWR VPWR sky130_fd_sc_hd__decap_3
XFILLER_43_445 VGND VGND VPWR VPWR sky130_fd_sc_hd__decap_3
XFILLER_70_253 VGND VGND VPWR VPWR sky130_fd_sc_hd__decap_3
XFILLER_102_94 VGND VGND VPWR VPWR sky130_fd_sc_hd__decap_3
XFILLER_30_106 VGND VGND VPWR VPWR sky130_fd_sc_hd__decap_3
XFILLER_31_629 VGND VGND VPWR VPWR sky130_fd_sc_hd__fill_1
XFILLER_62_32 VGND VGND VPWR VPWR sky130_fd_sc_hd__decap_3
XFILLER_70_286 VGND VGND VPWR VPWR sky130_fd_sc_hd__decap_3
XFILLER_11_320 VGND VGND VPWR VPWR sky130_fd_sc_hd__decap_3
XFILLER_62_65 VGND VGND VPWR VPWR sky130_fd_sc_hd__decap_3
XFILLER_7_27 VGND VGND VPWR VPWR sky130_fd_sc_hd__decap_3
XTAP_TAPCELL_ROW_96_1409 VGND VPWR sky130_fd_sc_hd__tapvpwrvgnd_1
XFILLER_112_406 VGND VGND VPWR VPWR sky130_fd_sc_hd__decap_3
XFILLER_3_596 VGND VGND VPWR VPWR sky130_fd_sc_hd__decap_3
XFILLER_97_128 VGND VGND VPWR VPWR sky130_fd_sc_hd__decap_3
XFILLER_78_342 VGND VGND VPWR VPWR sky130_fd_sc_hd__decap_3
XFILLER_38_206 VGND VGND VPWR VPWR sky130_fd_sc_hd__decap_3
XFILLER_66_526 VGND VGND VPWR VPWR sky130_fd_sc_hd__decap_3
XFILLER_16_6 VGND VGND VPWR VPWR sky130_fd_sc_hd__decap_3
XFILLER_66_548 VGND VGND VPWR VPWR sky130_fd_sc_hd__decap_3
XFILLER_93_389 VGND VGND VPWR VPWR sky130_fd_sc_hd__decap_3
XFILLER_34_412 VGND VGND VPWR VPWR sky130_fd_sc_hd__decap_3
XFILLER_61_220 VGND VGND VPWR VPWR sky130_fd_sc_hd__decap_3
XFILLER_74_581 VGND VGND VPWR VPWR sky130_fd_sc_hd__decap_3
XFILLER_74_592 VGND VGND VPWR VPWR sky130_fd_sc_hd__decap_3
XTAP_TAPCELL_ROW_105_1516 VGND VPWR sky130_fd_sc_hd__tapvpwrvgnd_1
XFILLER_34_467 VGND VGND VPWR VPWR sky130_fd_sc_hd__decap_3
XFILLER_61_231 VGND VGND VPWR VPWR sky130_fd_sc_hd__decap_3
XFILLER_15_670 VGND VGND VPWR VPWR sky130_fd_sc_hd__fill_2
XFILLER_61_264 VGND VGND VPWR VPWR sky130_fd_sc_hd__decap_3
XFILLER_99_3 VGND VGND VPWR VPWR sky130_fd_sc_hd__decap_3
XFILLER_14_191 VGND VGND VPWR VPWR sky130_fd_sc_hd__decap_3
XFILLER_21_128 VGND VGND VPWR VPWR sky130_fd_sc_hd__decap_3
X_4721_ _3535_/B _4658_/A _4055_/A VGND VGND VPWR VPWR _4721_/Y sky130_fd_sc_hd__a21oi_2
XTAP_TAPCELL_ROW_60_966 VGND VPWR sky130_fd_sc_hd__tapvpwrvgnd_1
XTAP_TAPCELL_ROW_32_635 VGND VPWR sky130_fd_sc_hd__tapvpwrvgnd_1
XFILLER_30_662 VGND VGND VPWR VPWR sky130_fd_sc_hd__decap_3
X_4652_ _4652_/A _4652_/B VGND VGND VPWR VPWR _4785_/A sky130_fd_sc_hd__nor2_2
XTAP_TAPCELL_ROW_60_977 VGND VPWR sky130_fd_sc_hd__tapvpwrvgnd_1
X_3603_ _4614_/B _3603_/B VGND VGND VPWR VPWR _3603_/Y sky130_fd_sc_hd__nand2_2
X_7371_ _7374_/CLK _7371_/D _6651_/Y VGND VGND VPWR VPWR _7371_/Q sky130_fd_sc_hd__dfrtp_2
Xhold803 _6910_/Q VGND VGND VPWR VPWR _6910_/D sky130_fd_sc_hd__dlygate4sd3_1
X_4583_ _4583_/A _4595_/B VGND VGND VPWR VPWR _7289_/D sky130_fd_sc_hd__and2_2
XTAP_TAPCELL_ROW_12_392 VGND VPWR sky130_fd_sc_hd__tapvpwrvgnd_1
XFILLER_115_211 VGND VGND VPWR VPWR sky130_fd_sc_hd__decap_3
Xhold814 _6773_/Q VGND VGND VPWR VPWR _6773_/D sky130_fd_sc_hd__dlygate4sd3_1
Xhold825 _6847_/Q VGND VGND VPWR VPWR _6847_/D sky130_fd_sc_hd__dlygate4sd3_1
Xhold836 _6772_/Q VGND VGND VPWR VPWR _6772_/D sky130_fd_sc_hd__dlygate4sd3_1
X_6322_ _6644_/A VGND VGND VPWR VPWR _6322_/Y sky130_fd_sc_hd__inv_2
X_3534_ _3509_/Y _3510_/X _4419_/B1 VGND VGND VPWR VPWR _3535_/B sky130_fd_sc_hd__a21oi_2
XTAP_TAPCELL_ROW_116_1656 VGND VPWR sky130_fd_sc_hd__tapvpwrvgnd_1
XTAP_TAPCELL_ROW_116_1645 VGND VPWR sky130_fd_sc_hd__tapvpwrvgnd_1
XFILLER_103_406 VGND VGND VPWR VPWR sky130_fd_sc_hd__decap_3
XFILLER_107_17 VGND VGND VPWR VPWR sky130_fd_sc_hd__decap_3
XFILLER_115_266 VGND VGND VPWR VPWR sky130_fd_sc_hd__decap_3
Xhold847 _7071_/Q VGND VGND VPWR VPWR _7071_/D sky130_fd_sc_hd__dlygate4sd3_1
Xhold858 _7058_/Q VGND VGND VPWR VPWR _7058_/D sky130_fd_sc_hd__dlygate4sd3_1
Xhold869 _7118_/Q VGND VGND VPWR VPWR _7118_/D sky130_fd_sc_hd__dlygate4sd3_1
Xmax_cap555 _4610_/A VGND VGND VPWR VPWR _4745_/A sky130_fd_sc_hd__clkbuf_2
X_3465_ _7185_/Q _3996_/S _4332_/B1 _7377_/Q VGND VGND VPWR VPWR _3465_/X sky130_fd_sc_hd__a22o_2
XFILLER_115_299 VGND VGND VPWR VPWR sky130_fd_sc_hd__decap_3
XFILLER_69_320 VGND VGND VPWR VPWR sky130_fd_sc_hd__fill_1
XFILLER_97_651 VGND VGND VPWR VPWR sky130_fd_sc_hd__decap_3
XTAP_TAPCELL_ROW_4_305 VGND VPWR sky130_fd_sc_hd__tapvpwrvgnd_1
XFILLER_69_364 VGND VGND VPWR VPWR sky130_fd_sc_hd__decap_3
XFILLER_84_312 VGND VGND VPWR VPWR sky130_fd_sc_hd__fill_1
XFILLER_96_150 VGND VGND VPWR VPWR sky130_fd_sc_hd__fill_2
XFILLER_97_673 VGND VGND VPWR VPWR sky130_fd_sc_hd__decap_3
X_5135_ _3371_/A _5666_/A _5581_/S _5134_/X VGND VGND VPWR VPWR _5135_/X sky130_fd_sc_hd__a211o_2
XFILLER_29_239 VGND VGND VPWR VPWR sky130_fd_sc_hd__decap_3
XFILLER_96_194 VGND VGND VPWR VPWR sky130_fd_sc_hd__fill_2
X_5066_ _5066_/A _5066_/B VGND VGND VPWR VPWR _6987_/D sky130_fd_sc_hd__nor2_2
XFILLER_44_209 VGND VGND VPWR VPWR sky130_fd_sc_hd__fill_2
XFILLER_72_507 VGND VGND VPWR VPWR sky130_fd_sc_hd__decap_3
XFILLER_72_518 VGND VGND VPWR VPWR sky130_fd_sc_hd__decap_3
X_4017_ _7310_/Q _4478_/S _4430_/B1 _7182_/Q VGND VGND VPWR VPWR _4017_/X sky130_fd_sc_hd__a22o_2
XFILLER_65_570 VGND VGND VPWR VPWR sky130_fd_sc_hd__decap_3
XFILLER_16_47 VGND VGND VPWR VPWR sky130_fd_sc_hd__decap_3
XFILLER_25_445 VGND VGND VPWR VPWR sky130_fd_sc_hd__decap_3
XFILLER_52_253 VGND VGND VPWR VPWR sky130_fd_sc_hd__decap_3
XFILLER_80_551 VGND VGND VPWR VPWR sky130_fd_sc_hd__decap_3
XFILLER_80_584 VGND VGND VPWR VPWR sky130_fd_sc_hd__fill_1
XFILLER_12_139 VGND VGND VPWR VPWR sky130_fd_sc_hd__fill_1
XFILLER_21_640 VGND VGND VPWR VPWR sky130_fd_sc_hd__decap_3
X_4919_ _4937_/A _4936_/B _4938_/B VGND VGND VPWR VPWR _4920_/B sky130_fd_sc_hd__o21ba_2
XFILLER_21_673 VGND VGND VPWR VPWR sky130_fd_sc_hd__fill_1
XFILLER_32_24 VGND VGND VPWR VPWR sky130_fd_sc_hd__decap_3
XFILLER_32_35 VGND VGND VPWR VPWR sky130_fd_sc_hd__decap_3
XFILLER_20_183 VGND VGND VPWR VPWR sky130_fd_sc_hd__decap_3
XFILLER_32_68 VGND VGND VPWR VPWR sky130_fd_sc_hd__decap_3
XFILLER_106_200 VGND VGND VPWR VPWR sky130_fd_sc_hd__fill_2
XFILLER_106_211 VGND VGND VPWR VPWR sky130_fd_sc_hd__decap_3
XFILLER_4_338 VGND VGND VPWR VPWR sky130_fd_sc_hd__fill_1
XFILLER_79_106 VGND VGND VPWR VPWR sky130_fd_sc_hd__decap_3
XFILLER_79_128 VGND VGND VPWR VPWR sky130_fd_sc_hd__decap_3
XTAP_TAPCELL_ROW_91_1339 VGND VPWR sky130_fd_sc_hd__tapvpwrvgnd_1
XFILLER_0_533 VGND VGND VPWR VPWR sky130_fd_sc_hd__fill_1
XFILLER_0_555 VGND VGND VPWR VPWR sky130_fd_sc_hd__decap_3
XFILLER_88_651 VGND VGND VPWR VPWR sky130_fd_sc_hd__decap_3
XFILLER_57_21 VGND VGND VPWR VPWR sky130_fd_sc_hd__decap_3
XFILLER_87_161 VGND VGND VPWR VPWR sky130_fd_sc_hd__decap_3
XFILLER_87_172 VGND VGND VPWR VPWR sky130_fd_sc_hd__fill_2
XFILLER_102_483 VGND VGND VPWR VPWR sky130_fd_sc_hd__decap_3
XFILLER_57_54 VGND VGND VPWR VPWR sky130_fd_sc_hd__fill_2
XFILLER_57_87 VGND VGND VPWR VPWR sky130_fd_sc_hd__decap_3
XFILLER_87_183 VGND VGND VPWR VPWR sky130_fd_sc_hd__fill_2
XFILLER_63_529 VGND VGND VPWR VPWR sky130_fd_sc_hd__decap_3
XFILLER_90_304 VGND VGND VPWR VPWR sky130_fd_sc_hd__decap_3
XFILLER_113_60 VGND VGND VPWR VPWR sky130_fd_sc_hd__decap_3
XFILLER_90_315 VGND VGND VPWR VPWR sky130_fd_sc_hd__decap_3
XFILLER_90_348 VGND VGND VPWR VPWR sky130_fd_sc_hd__decap_3
XFILLER_113_93 VGND VGND VPWR VPWR sky130_fd_sc_hd__decap_3
XFILLER_28_294 VGND VGND VPWR VPWR sky130_fd_sc_hd__decap_3
XFILLER_43_220 VGND VGND VPWR VPWR sky130_fd_sc_hd__decap_3
XFILLER_73_64 VGND VGND VPWR VPWR sky130_fd_sc_hd__decap_3
XTAP_TAPCELL_ROW_100_1457 VGND VPWR sky130_fd_sc_hd__tapvpwrvgnd_1
XTAP_TAPCELL_ROW_100_1446 VGND VPWR sky130_fd_sc_hd__tapvpwrvgnd_1
XFILLER_11_172 VGND VGND VPWR VPWR sky130_fd_sc_hd__decap_3
XFILLER_7_143 VGND VGND VPWR VPWR sky130_fd_sc_hd__decap_3
XFILLER_98_404 VGND VGND VPWR VPWR sky130_fd_sc_hd__decap_3
XFILLER_112_203 VGND VGND VPWR VPWR sky130_fd_sc_hd__decap_3
XFILLER_98_72 VGND VGND VPWR VPWR sky130_fd_sc_hd__decap_3
XFILLER_112_236 VGND VGND VPWR VPWR sky130_fd_sc_hd__decap_3
XFILLER_3_393 VGND VGND VPWR VPWR sky130_fd_sc_hd__decap_3
XFILLER_98_459 VGND VGND VPWR VPWR sky130_fd_sc_hd__decap_3
XFILLER_100_409 VGND VGND VPWR VPWR sky130_fd_sc_hd__fill_2
XFILLER_78_150 VGND VGND VPWR VPWR sky130_fd_sc_hd__decap_3
XFILLER_79_673 VGND VGND VPWR VPWR sky130_fd_sc_hd__decap_3
XTAP_TAPCELL_ROW_111_1586 VGND VPWR sky130_fd_sc_hd__tapvpwrvgnd_1
XFILLER_14_3 VGND VGND VPWR VPWR sky130_fd_sc_hd__decap_3
XFILLER_39_559 VGND VGND VPWR VPWR sky130_fd_sc_hd__fill_1
XFILLER_66_334 VGND VGND VPWR VPWR sky130_fd_sc_hd__decap_3
XFILLER_93_131 VGND VGND VPWR VPWR sky130_fd_sc_hd__decap_3
XFILLER_94_632 VGND VGND VPWR VPWR sky130_fd_sc_hd__decap_3
XFILLER_94_654 VGND VGND VPWR VPWR sky130_fd_sc_hd__decap_3
XFILLER_19_250 VGND VGND VPWR VPWR sky130_fd_sc_hd__decap_3
XFILLER_26_209 VGND VGND VPWR VPWR sky130_fd_sc_hd__decap_3
XFILLER_66_378 VGND VGND VPWR VPWR sky130_fd_sc_hd__decap_3
XFILLER_94_687 VGND VGND VPWR VPWR sky130_fd_sc_hd__decap_3
X_6940_ _7005_/CLK _6940_/D VGND VGND VPWR VPWR _6940_/Q sky130_fd_sc_hd__dfxtp_2
XFILLER_47_592 VGND VGND VPWR VPWR sky130_fd_sc_hd__decap_3
XFILLER_81_337 VGND VGND VPWR VPWR sky130_fd_sc_hd__decap_3
XFILLER_34_242 VGND VGND VPWR VPWR sky130_fd_sc_hd__decap_3
X_6871_ _7384_/CLK _6871_/D VGND VGND VPWR VPWR _6871_/Q sky130_fd_sc_hd__dfxtp_2
XTAP_TAPCELL_ROW_66_1043 VGND VPWR sky130_fd_sc_hd__tapvpwrvgnd_1
XFILLER_22_404 VGND VGND VPWR VPWR sky130_fd_sc_hd__decap_3
XFILLER_22_415 VGND VGND VPWR VPWR sky130_fd_sc_hd__decap_3
XFILLER_34_253 VGND VGND VPWR VPWR sky130_fd_sc_hd__decap_3
XTAP_TAPCELL_ROW_17_451 VGND VPWR sky130_fd_sc_hd__tapvpwrvgnd_1
XTAP_TAPCELL_ROW_45_793 VGND VPWR sky130_fd_sc_hd__tapvpwrvgnd_1
X_4704_ _6994_/Q _4977_/A VGND VGND VPWR VPWR _4963_/A sky130_fd_sc_hd__and2_2
X_5684_ _7348_/Q hold957/X _5708_/S VGND VGND VPWR VPWR _6692_/D sky130_fd_sc_hd__mux2_2
X_4635_ _4916_/A _4916_/B _4633_/X _4634_/Y VGND VGND VPWR VPWR _4646_/A sky130_fd_sc_hd__a211o_2
XFILLER_116_531 VGND VGND VPWR VPWR sky130_fd_sc_hd__fill_1
X_7354_ _7386_/CLK _7354_/D _6634_/Y VGND VGND VPWR VPWR _7354_/Q sky130_fd_sc_hd__dfrtp_2
Xhold600 _6975_/Q VGND VGND VPWR VPWR _6975_/D sky130_fd_sc_hd__dlygate4sd3_1
Xhold611 _6738_/Q VGND VGND VPWR VPWR _6738_/D sky130_fd_sc_hd__dlygate4sd3_1
XFILLER_116_542 VGND VGND VPWR VPWR sky130_fd_sc_hd__decap_3
XFILLER_116_564 VGND VGND VPWR VPWR sky130_fd_sc_hd__fill_2
Xhold622 _6783_/Q VGND VGND VPWR VPWR _6783_/D sky130_fd_sc_hd__dlygate4sd3_1
Xhold633 _6897_/Q VGND VGND VPWR VPWR _6897_/D sky130_fd_sc_hd__dlygate4sd3_1
Xhold644 _6731_/Q VGND VGND VPWR VPWR _6731_/D sky130_fd_sc_hd__dlygate4sd3_1
X_6305_ _6647_/A VGND VGND VPWR VPWR _6305_/Y sky130_fd_sc_hd__inv_2
X_3517_ _3386_/B _3370_/Y _3516_/X VGND VGND VPWR VPWR _3525_/A sky130_fd_sc_hd__a21bo_2
XTAP_TAPCELL_ROW_77_1172 VGND VPWR sky130_fd_sc_hd__tapvpwrvgnd_1
XFILLER_103_225 VGND VGND VPWR VPWR sky130_fd_sc_hd__decap_3
XFILLER_116_586 VGND VGND VPWR VPWR sky130_fd_sc_hd__fill_2
XFILLER_89_426 VGND VGND VPWR VPWR sky130_fd_sc_hd__decap_3
X_7285_ clkload5/A _7285_/D _6565_/Y VGND VGND VPWR VPWR _7285_/Q sky130_fd_sc_hd__dfrtp_2
Xhold655 _6960_/Q VGND VGND VPWR VPWR _6960_/D sky130_fd_sc_hd__dlygate4sd3_1
Xhold666 _6873_/Q VGND VGND VPWR VPWR _6873_/D sky130_fd_sc_hd__dlygate4sd3_1
Xhold677 _6878_/Q VGND VGND VPWR VPWR _6878_/D sky130_fd_sc_hd__dlygate4sd3_1
Xhold688 _6917_/Q VGND VGND VPWR VPWR _6917_/D sky130_fd_sc_hd__dlygate4sd3_1
X_4497_ _4497_/A0 _7299_/Q _4501_/S VGND VGND VPWR VPWR _7331_/D sky130_fd_sc_hd__mux2_2
Xhold699 _6941_/Q VGND VGND VPWR VPWR _6941_/D sky130_fd_sc_hd__dlygate4sd3_1
X_3448_ _7282_/Q _5159_/S _3409_/X _7154_/Q _3447_/X VGND VGND VPWR VPWR _3448_/X
+ sky130_fd_sc_hd__a221o_2
XFILLER_103_269 VGND VGND VPWR VPWR sky130_fd_sc_hd__decap_3
XFILLER_69_161 VGND VGND VPWR VPWR sky130_fd_sc_hd__decap_3
X_3379_ _7219_/Q _4340_/A2 _4235_/B1 _7123_/Q VGND VGND VPWR VPWR _3379_/X sky130_fd_sc_hd__a22o_2
XFILLER_57_312 VGND VGND VPWR VPWR sky130_fd_sc_hd__decap_3
XFILLER_69_172 VGND VGND VPWR VPWR sky130_fd_sc_hd__decap_3
XFILLER_85_643 VGND VGND VPWR VPWR sky130_fd_sc_hd__decap_3
X_5118_ _5118_/A _6984_/Q _5118_/C _5118_/D VGND VGND VPWR VPWR _5118_/X sky130_fd_sc_hd__or4_2
XFILLER_84_153 VGND VGND VPWR VPWR sky130_fd_sc_hd__decap_3
XFILLER_84_164 VGND VGND VPWR VPWR sky130_fd_sc_hd__decap_3
XFILLER_85_676 VGND VGND VPWR VPWR sky130_fd_sc_hd__decap_3
XFILLER_27_46 VGND VGND VPWR VPWR sky130_fd_sc_hd__decap_3
XFILLER_72_315 VGND VGND VPWR VPWR sky130_fd_sc_hd__fill_2
XFILLER_84_197 VGND VGND VPWR VPWR sky130_fd_sc_hd__fill_2
X_5049_ _5072_/B _5073_/B _5071_/B VGND VGND VPWR VPWR _5049_/X sky130_fd_sc_hd__a21bo_2
XFILLER_25_242 VGND VGND VPWR VPWR sky130_fd_sc_hd__decap_3
XFILLER_53_540 VGND VGND VPWR VPWR sky130_fd_sc_hd__decap_3
XFILLER_25_275 VGND VGND VPWR VPWR sky130_fd_sc_hd__decap_3
XFILLER_40_201 VGND VGND VPWR VPWR sky130_fd_sc_hd__decap_3
XFILLER_43_23 VGND VGND VPWR VPWR sky130_fd_sc_hd__decap_3
XFILLER_43_45 VGND VGND VPWR VPWR sky130_fd_sc_hd__decap_3
XFILLER_53_595 VGND VGND VPWR VPWR sky130_fd_sc_hd__decap_3
XFILLER_43_78 VGND VGND VPWR VPWR sky130_fd_sc_hd__fill_2
XFILLER_40_289 VGND VGND VPWR VPWR sky130_fd_sc_hd__decap_3
XFILLER_21_492 VGND VGND VPWR VPWR sky130_fd_sc_hd__decap_3
XFILLER_5_614 VGND VGND VPWR VPWR sky130_fd_sc_hd__fill_2
XFILLER_4_124 VGND VGND VPWR VPWR sky130_fd_sc_hd__decap_3
XFILLER_107_564 VGND VGND VPWR VPWR sky130_fd_sc_hd__decap_3
XFILLER_5_658 VGND VGND VPWR VPWR sky130_fd_sc_hd__decap_3
XFILLER_108_71 VGND VGND VPWR VPWR sky130_fd_sc_hd__decap_3
XFILLER_68_20 VGND VGND VPWR VPWR sky130_fd_sc_hd__decap_3
XFILLER_68_75 VGND VGND VPWR VPWR sky130_fd_sc_hd__decap_3
XFILLER_76_610 VGND VGND VPWR VPWR sky130_fd_sc_hd__decap_3
XFILLER_88_470 VGND VGND VPWR VPWR sky130_fd_sc_hd__decap_3
XFILLER_95_407 VGND VGND VPWR VPWR sky130_fd_sc_hd__decap_3
XFILLER_0_385 VGND VGND VPWR VPWR sky130_fd_sc_hd__decap_3
XFILLER_0_396 VGND VGND VPWR VPWR sky130_fd_sc_hd__decap_3
XFILLER_48_312 VGND VGND VPWR VPWR sky130_fd_sc_hd__decap_3
XFILLER_48_334 VGND VGND VPWR VPWR sky130_fd_sc_hd__decap_3
XFILLER_68_97 VGND VGND VPWR VPWR sky130_fd_sc_hd__fill_1
XFILLER_76_643 VGND VGND VPWR VPWR sky130_fd_sc_hd__fill_1
XFILLER_36_518 VGND VGND VPWR VPWR sky130_fd_sc_hd__decap_3
XFILLER_48_356 VGND VGND VPWR VPWR sky130_fd_sc_hd__decap_3
XFILLER_48_378 VGND VGND VPWR VPWR sky130_fd_sc_hd__fill_2
XFILLER_75_131 VGND VGND VPWR VPWR sky130_fd_sc_hd__fill_2
XFILLER_75_153 VGND VGND VPWR VPWR sky130_fd_sc_hd__fill_2
XFILLER_76_687 VGND VGND VPWR VPWR sky130_fd_sc_hd__decap_3
XFILLER_84_41 VGND VGND VPWR VPWR sky130_fd_sc_hd__decap_3
XFILLER_91_613 VGND VGND VPWR VPWR sky130_fd_sc_hd__decap_3
XFILLER_63_337 VGND VGND VPWR VPWR sky130_fd_sc_hd__decap_3
XFILLER_75_175 VGND VGND VPWR VPWR sky130_fd_sc_hd__decap_3
XFILLER_84_74 VGND VGND VPWR VPWR sky130_fd_sc_hd__decap_3
XFILLER_90_112 VGND VGND VPWR VPWR sky130_fd_sc_hd__decap_3
Xplace304 _3605_/Y VGND VGND VPWR VPWR _5146_/B1 sky130_fd_sc_hd__buf_2
XFILLER_84_85 VGND VGND VPWR VPWR sky130_fd_sc_hd__decap_3
XFILLER_90_134 VGND VGND VPWR VPWR sky130_fd_sc_hd__decap_3
XFILLER_91_679 VGND VGND VPWR VPWR sky130_fd_sc_hd__decap_3
Xplace337 _5396_/S VGND VGND VPWR VPWR _5383_/S sky130_fd_sc_hd__buf_2
Xplace326 _5721_/S VGND VGND VPWR VPWR _5708_/S sky130_fd_sc_hd__buf_2
Xplace315 _5245_/S VGND VGND VPWR VPWR _5274_/S sky130_fd_sc_hd__buf_2
XFILLER_16_253 VGND VGND VPWR VPWR sky130_fd_sc_hd__decap_3
XFILLER_71_370 VGND VGND VPWR VPWR sky130_fd_sc_hd__decap_3
Xplace359 _3409_/X VGND VGND VPWR VPWR _4267_/B1 sky130_fd_sc_hd__buf_2
Xplace348 _4351_/A2 VGND VGND VPWR VPWR _4434_/A2 sky130_fd_sc_hd__buf_2
XFILLER_16_297 VGND VGND VPWR VPWR sky130_fd_sc_hd__decap_3
XFILLER_31_223 VGND VGND VPWR VPWR sky130_fd_sc_hd__fill_1
XFILLER_44_595 VGND VGND VPWR VPWR sky130_fd_sc_hd__fill_1
XTAP_TAPCELL_ROW_14_421 VGND VPWR sky130_fd_sc_hd__tapvpwrvgnd_1
XFILLER_31_256 VGND VGND VPWR VPWR sky130_fd_sc_hd__decap_3
XTAP_TAPCELL_ROW_42_752 VGND VPWR sky130_fd_sc_hd__tapvpwrvgnd_1
XFILLER_12_470 VGND VGND VPWR VPWR sky130_fd_sc_hd__decap_3
X_4420_ _7336_/Q _3958_/S _4428_/B1 _7144_/Q VGND VGND VPWR VPWR _4420_/X sky130_fd_sc_hd__a22o_2
XTAP_TAPCELL_ROW_113_1604 VGND VPWR sky130_fd_sc_hd__tapvpwrvgnd_1
X_4351_ _7097_/Q _4351_/A2 _4351_/B1 _7129_/Q VGND VGND VPWR VPWR _4351_/X sky130_fd_sc_hd__a22o_2
X_7070_ _7330_/CLK _7070_/D _6350_/Y VGND VGND VPWR VPWR _7070_/Q sky130_fd_sc_hd__dfrtp_2
X_4282_ _7062_/Q _3577_/B _3590_/A _4281_/X VGND VGND VPWR VPWR _4294_/A sky130_fd_sc_hd__o211ai_2
X_3302_ _6980_/Q _6979_/Q _6981_/Q VGND VGND VPWR VPWR _3302_/X sky130_fd_sc_hd__a21o_2
XFILLER_98_245 VGND VGND VPWR VPWR sky130_fd_sc_hd__decap_3
XFILLER_58_109 VGND VGND VPWR VPWR sky130_fd_sc_hd__decap_3
XFILLER_67_610 VGND VGND VPWR VPWR sky130_fd_sc_hd__fill_1
XFILLER_86_418 VGND VGND VPWR VPWR sky130_fd_sc_hd__fill_2
XFILLER_100_228 VGND VGND VPWR VPWR sky130_fd_sc_hd__decap_3
XFILLER_104_18 VGND VGND VPWR VPWR sky130_fd_sc_hd__decap_3
XFILLER_104_29 VGND VGND VPWR VPWR sky130_fd_sc_hd__decap_3
XFILLER_66_153 VGND VGND VPWR VPWR sky130_fd_sc_hd__fill_2
XFILLER_67_676 VGND VGND VPWR VPWR sky130_fd_sc_hd__decap_3
XFILLER_27_529 VGND VGND VPWR VPWR sky130_fd_sc_hd__decap_3
XFILLER_54_304 VGND VGND VPWR VPWR sky130_fd_sc_hd__decap_3
XFILLER_66_175 VGND VGND VPWR VPWR sky130_fd_sc_hd__decap_3
XFILLER_81_101 VGND VGND VPWR VPWR sky130_fd_sc_hd__decap_3
XFILLER_82_613 VGND VGND VPWR VPWR sky130_fd_sc_hd__decap_3
XFILLER_66_197 VGND VGND VPWR VPWR sky130_fd_sc_hd__fill_2
XFILLER_82_657 VGND VGND VPWR VPWR sky130_fd_sc_hd__decap_3
X_6923_ _6959_/CLK _6923_/D VGND VGND VPWR VPWR _6923_/Q sky130_fd_sc_hd__dfxtp_2
XFILLER_81_167 VGND VGND VPWR VPWR sky130_fd_sc_hd__fill_1
XFILLER_22_212 VGND VGND VPWR VPWR sky130_fd_sc_hd__decap_3
XFILLER_35_595 VGND VGND VPWR VPWR sky130_fd_sc_hd__fill_1
Xfanout16 _6347_/A VGND VGND VPWR VPWR _6568_/A sky130_fd_sc_hd__clkbuf_2
Xfanout27 _6664_/A VGND VGND VPWR VPWR _6634_/A sky130_fd_sc_hd__buf_2
Xfanout38 fanout39/X VGND VGND VPWR VPWR fanout38/X sky130_fd_sc_hd__clkdlybuf4s25_1
X_6854_ _6966_/CLK _6854_/D VGND VGND VPWR VPWR _6854_/Q sky130_fd_sc_hd__dfxtp_2
XFILLER_10_407 VGND VGND VPWR VPWR sky130_fd_sc_hd__decap_3
Xfanout49 fanout51/X VGND VGND VPWR VPWR _6366_/A sky130_fd_sc_hd__buf_2
X_6785_ _6977_/CLK _6785_/D VGND VGND VPWR VPWR _6785_/Q sky130_fd_sc_hd__dfxtp_2
XFILLER_13_26 VGND VGND VPWR VPWR sky130_fd_sc_hd__decap_3
XFILLER_22_278 VGND VGND VPWR VPWR sky130_fd_sc_hd__decap_3
XFILLER_50_587 VGND VGND VPWR VPWR sky130_fd_sc_hd__fill_1
XFILLER_108_306 VGND VGND VPWR VPWR sky130_fd_sc_hd__fill_2
X_5667_ _6979_/Q _5668_/B VGND VGND VPWR VPWR _6979_/D sky130_fd_sc_hd__nor2_2
XTAP_TAPCELL_ROW_79_1201 VGND VPWR sky130_fd_sc_hd__tapvpwrvgnd_1
X_7406_ _7406_/CLK _7406_/D _6686_/Y VGND VGND VPWR VPWR _7406_/Q sky130_fd_sc_hd__dfrtp_2
XFILLER_2_606 VGND VGND VPWR VPWR sky130_fd_sc_hd__decap_3
X_5598_ hold940/X _4960_/A _4468_/X VGND VGND VPWR VPWR _7028_/D sky130_fd_sc_hd__a21o_2
XFILLER_116_350 VGND VGND VPWR VPWR sky130_fd_sc_hd__decap_3
XFILLER_1_105 VGND VGND VPWR VPWR sky130_fd_sc_hd__decap_3
XFILLER_1_116 VGND VGND VPWR VPWR sky130_fd_sc_hd__decap_3
XFILLER_2_639 VGND VGND VPWR VPWR sky130_fd_sc_hd__decap_3
X_7337_ _7369_/CLK _7337_/D _6617_/Y VGND VGND VPWR VPWR _7337_/Q sky130_fd_sc_hd__dfrtp_2
XFILLER_89_223 VGND VGND VPWR VPWR sky130_fd_sc_hd__fill_1
X_7268_ _7330_/CLK _7268_/D _6548_/Y VGND VGND VPWR VPWR _7268_/Q sky130_fd_sc_hd__dfrtp_2
XFILLER_104_578 VGND VGND VPWR VPWR sky130_fd_sc_hd__decap_3
XFILLER_104_589 VGND VGND VPWR VPWR sky130_fd_sc_hd__decap_3
XFILLER_38_12 VGND VGND VPWR VPWR sky130_fd_sc_hd__decap_3
XFILLER_89_278 VGND VGND VPWR VPWR sky130_fd_sc_hd__fill_2
XFILLER_58_621 VGND VGND VPWR VPWR sky130_fd_sc_hd__decap_3
X_7199_ _7264_/CLK _7199_/D _6479_/Y VGND VGND VPWR VPWR _7199_/Q sky130_fd_sc_hd__dfrtp_2
XFILLER_18_507 VGND VGND VPWR VPWR sky130_fd_sc_hd__decap_3
XFILLER_38_67 VGND VGND VPWR VPWR sky130_fd_sc_hd__decap_3
XFILLER_58_654 VGND VGND VPWR VPWR sky130_fd_sc_hd__decap_3
Xhold1130 _7236_/Q VGND VGND VPWR VPWR _5184_/A sky130_fd_sc_hd__dlygate4sd3_1
Xhold1141 _3964_/X VGND VGND VPWR VPWR _7358_/D sky130_fd_sc_hd__dlygate4sd3_1
XFILLER_45_326 VGND VGND VPWR VPWR sky130_fd_sc_hd__fill_2
XFILLER_57_164 VGND VGND VPWR VPWR sky130_fd_sc_hd__decap_3
XFILLER_57_186 VGND VGND VPWR VPWR sky130_fd_sc_hd__decap_3
XFILLER_73_635 VGND VGND VPWR VPWR sky130_fd_sc_hd__decap_3
Xhold1152 _7125_/Q VGND VGND VPWR VPWR _5417_/A0 sky130_fd_sc_hd__dlygate4sd3_1
Xhold1163 _7127_/Q VGND VGND VPWR VPWR _5413_/A0 sky130_fd_sc_hd__dlygate4sd3_1
Xhold1174 _7226_/Q VGND VGND VPWR VPWR _5205_/A sky130_fd_sc_hd__dlygate4sd3_1
Xhold1185 _7181_/Q VGND VGND VPWR VPWR _5298_/A0 sky130_fd_sc_hd__dlygate4sd3_1
XFILLER_45_337 VGND VGND VPWR VPWR sky130_fd_sc_hd__decap_3
XFILLER_73_657 VGND VGND VPWR VPWR sky130_fd_sc_hd__decap_3
XFILLER_73_679 VGND VGND VPWR VPWR sky130_fd_sc_hd__decap_3
Xhold1196 _7283_/Q VGND VGND VPWR VPWR _4595_/A sky130_fd_sc_hd__dlygate4sd3_1
XFILLER_54_44 VGND VGND VPWR VPWR sky130_fd_sc_hd__decap_3
XFILLER_60_318 VGND VGND VPWR VPWR sky130_fd_sc_hd__decap_3
XFILLER_72_167 VGND VGND VPWR VPWR sky130_fd_sc_hd__decap_3
XFILLER_13_223 VGND VGND VPWR VPWR sky130_fd_sc_hd__fill_1
XFILLER_13_234 VGND VGND VPWR VPWR sky130_fd_sc_hd__decap_3
XFILLER_26_595 VGND VGND VPWR VPWR sky130_fd_sc_hd__decap_3
XFILLER_41_532 VGND VGND VPWR VPWR sky130_fd_sc_hd__fill_1
XFILLER_54_77 VGND VGND VPWR VPWR sky130_fd_sc_hd__decap_3
XFILLER_54_88 VGND VGND VPWR VPWR sky130_fd_sc_hd__decap_3
XFILLER_110_50 VGND VGND VPWR VPWR sky130_fd_sc_hd__decap_3
XFILLER_13_267 VGND VGND VPWR VPWR sky130_fd_sc_hd__decap_3
XFILLER_9_216 VGND VGND VPWR VPWR sky130_fd_sc_hd__decap_3
XFILLER_110_83 VGND VGND VPWR VPWR sky130_fd_sc_hd__fill_1
XFILLER_110_94 VGND VGND VPWR VPWR sky130_fd_sc_hd__fill_1
XFILLER_70_21 VGND VGND VPWR VPWR sky130_fd_sc_hd__decap_3
XFILLER_70_32 VGND VGND VPWR VPWR sky130_fd_sc_hd__decap_3
XFILLER_70_76 VGND VGND VPWR VPWR sky130_fd_sc_hd__decap_3
XFILLER_5_422 VGND VGND VPWR VPWR sky130_fd_sc_hd__decap_3
XFILLER_70_98 VGND VGND VPWR VPWR sky130_fd_sc_hd__decap_3
Xclkload19 _6965_/CLK VGND VGND VPWR VPWR clkload19/X sky130_fd_sc_hd__clkbuf_1
XFILLER_114_309 VGND VGND VPWR VPWR sky130_fd_sc_hd__decap_3
XFILLER_5_444 VGND VGND VPWR VPWR sky130_fd_sc_hd__decap_3
XFILLER_79_63 VGND VGND VPWR VPWR sky130_fd_sc_hd__decap_3
XFILLER_107_383 VGND VGND VPWR VPWR sky130_fd_sc_hd__decap_3
XFILLER_1_650 VGND VGND VPWR VPWR sky130_fd_sc_hd__decap_3
XFILLER_49_632 VGND VGND VPWR VPWR sky130_fd_sc_hd__decap_3
XFILLER_48_153 VGND VGND VPWR VPWR sky130_fd_sc_hd__decap_3
XFILLER_49_665 VGND VGND VPWR VPWR sky130_fd_sc_hd__decap_3
XFILLER_49_676 VGND VGND VPWR VPWR sky130_fd_sc_hd__decap_3
XFILLER_95_84 VGND VGND VPWR VPWR sky130_fd_sc_hd__decap_3
XFILLER_36_326 VGND VGND VPWR VPWR sky130_fd_sc_hd__decap_3
XTAP_TAPCELL_ROW_47_811 VGND VPWR sky130_fd_sc_hd__tapvpwrvgnd_1
XFILLER_48_197 VGND VGND VPWR VPWR sky130_fd_sc_hd__decap_3
XFILLER_64_657 VGND VGND VPWR VPWR sky130_fd_sc_hd__decap_3
XFILLER_91_432 VGND VGND VPWR VPWR sky130_fd_sc_hd__decap_3
XFILLER_51_329 VGND VGND VPWR VPWR sky130_fd_sc_hd__decap_3
XFILLER_63_156 VGND VGND VPWR VPWR sky130_fd_sc_hd__decap_3
X_3920_ _3920_/A1 _5151_/A _3919_/X VGND VGND VPWR VPWR _7377_/D sky130_fd_sc_hd__o21a_2
XFILLER_32_521 VGND VGND VPWR VPWR sky130_fd_sc_hd__decap_3
XFILLER_72_690 VGND VGND VPWR VPWR sky130_fd_sc_hd__fill_2
XTAP_TAPCELL_ROW_63_1013 VGND VPWR sky130_fd_sc_hd__tapvpwrvgnd_1
XTAP_TAPCELL_ROW_63_1002 VGND VPWR sky130_fd_sc_hd__tapvpwrvgnd_1
X_3851_ _6825_/Q _3886_/A2 _3886_/B1 _6815_/Q _3850_/X VGND VGND VPWR VPWR _3851_/X
+ sky130_fd_sc_hd__a221o_2
XFILLER_32_587 VGND VGND VPWR VPWR sky130_fd_sc_hd__fill_1
XFILLER_81_3 VGND VGND VPWR VPWR sky130_fd_sc_hd__decap_3
X_6570_ _6570_/A VGND VGND VPWR VPWR _6570_/Y sky130_fd_sc_hd__inv_2
X_3782_ _6827_/Q _3886_/A2 _3651_/Y _6817_/Q VGND VGND VPWR VPWR _3782_/X sky130_fd_sc_hd__a22o_2
XFILLER_8_260 VGND VGND VPWR VPWR sky130_fd_sc_hd__decap_3
Xoutput502 _3421_/B VGND VGND VPWR VPWR instruction_out[20] sky130_fd_sc_hd__clkdlybuf4s25_1
Xoutput535 _7000_/Q VGND VGND VPWR VPWR pc_out[23] sky130_fd_sc_hd__clkdlybuf4s25_1
Xoutput524 _6990_/Q VGND VGND VPWR VPWR pc_out[13] sky130_fd_sc_hd__clkdlybuf4s25_1
Xoutput513 _5640_/A VGND VGND VPWR VPWR instruction_out[3] sky130_fd_sc_hd__clkdlybuf4s25_1
X_5383_ _5383_/A0 _4878_/X _5383_/S VGND VGND VPWR VPWR _7141_/D sky130_fd_sc_hd__mux2_2
X_4403_ _4403_/A VGND VGND VPWR VPWR _4411_/A sky130_fd_sc_hd__inv_2
XFILLER_5_60 VGND VGND VPWR VPWR sky130_fd_sc_hd__decap_3
X_7122_ clkload6/A _7122_/D _6402_/Y VGND VGND VPWR VPWR _7122_/Q sky130_fd_sc_hd__dfrtp_2
Xoutput546 _6981_/Q VGND VGND VPWR VPWR pc_out[4] sky130_fd_sc_hd__clkdlybuf4s25_1
X_4334_ _7351_/Q _3449_/X _3409_/X _7159_/Q VGND VGND VPWR VPWR _4336_/B sky130_fd_sc_hd__a22o_2
XTAP_TAPCELL_ROW_74_1142 VGND VPWR sky130_fd_sc_hd__tapvpwrvgnd_1
XFILLER_99_543 VGND VGND VPWR VPWR sky130_fd_sc_hd__decap_3
XFILLER_115_17 VGND VGND VPWR VPWR sky130_fd_sc_hd__decap_3
XFILLER_59_418 VGND VGND VPWR VPWR sky130_fd_sc_hd__decap_3
XFILLER_5_93 VGND VGND VPWR VPWR sky130_fd_sc_hd__decap_3
X_7053_ _7341_/CLK _7053_/D _6333_/Y VGND VGND VPWR VPWR _7053_/Q sky130_fd_sc_hd__dfrtp_2
XFILLER_99_587 VGND VGND VPWR VPWR sky130_fd_sc_hd__decap_3
XFILLER_101_526 VGND VGND VPWR VPWR sky130_fd_sc_hd__decap_3
XFILLER_86_226 VGND VGND VPWR VPWR sky130_fd_sc_hd__fill_2
XFILLER_86_248 VGND VGND VPWR VPWR sky130_fd_sc_hd__decap_3
X_4265_ _7070_/Q _4265_/B VGND VGND VPWR VPWR _4376_/C sky130_fd_sc_hd__nor2_2
XFILLER_101_559 VGND VGND VPWR VPWR sky130_fd_sc_hd__fill_1
XFILLER_39_131 VGND VGND VPWR VPWR sky130_fd_sc_hd__decap_3
XFILLER_86_259 VGND VGND VPWR VPWR sky130_fd_sc_hd__decap_3
X_4196_ _7391_/Q _4196_/A2 _5028_/S _7295_/Q _4195_/X VGND VGND VPWR VPWR _4196_/X
+ sky130_fd_sc_hd__a221o_2
XFILLER_27_304 VGND VGND VPWR VPWR sky130_fd_sc_hd__decap_3
XFILLER_55_635 VGND VGND VPWR VPWR sky130_fd_sc_hd__decap_3
XFILLER_82_410 VGND VGND VPWR VPWR sky130_fd_sc_hd__decap_3
XFILLER_27_337 VGND VGND VPWR VPWR sky130_fd_sc_hd__fill_1
XFILLER_55_668 VGND VGND VPWR VPWR sky130_fd_sc_hd__decap_3
XFILLER_82_421 VGND VGND VPWR VPWR sky130_fd_sc_hd__decap_3
XFILLER_82_432 VGND VGND VPWR VPWR sky130_fd_sc_hd__fill_2
XFILLER_94_292 VGND VGND VPWR VPWR sky130_fd_sc_hd__fill_1
XFILLER_55_679 VGND VGND VPWR VPWR sky130_fd_sc_hd__decap_3
XFILLER_23_532 VGND VGND VPWR VPWR sky130_fd_sc_hd__fill_2
XFILLER_24_14 VGND VGND VPWR VPWR sky130_fd_sc_hd__decap_3
XFILLER_42_329 VGND VGND VPWR VPWR sky130_fd_sc_hd__decap_3
XFILLER_82_498 VGND VGND VPWR VPWR sky130_fd_sc_hd__decap_3
X_6906_ _6911_/CLK _6906_/D VGND VGND VPWR VPWR _6906_/Q sky130_fd_sc_hd__dfxtp_2
XTAP_TAPCELL_ROW_85_1271 VGND VPWR sky130_fd_sc_hd__tapvpwrvgnd_1
XTAP_TAPCELL_ROW_25_549 VGND VPWR sky130_fd_sc_hd__tapvpwrvgnd_1
XFILLER_23_554 VGND VGND VPWR VPWR sky130_fd_sc_hd__decap_3
XFILLER_24_47 VGND VGND VPWR VPWR sky130_fd_sc_hd__fill_2
XFILLER_50_351 VGND VGND VPWR VPWR sky130_fd_sc_hd__decap_3
X_6837_ _6978_/CLK _6837_/D VGND VGND VPWR VPWR _6837_/Q sky130_fd_sc_hd__dfxtp_2
XFILLER_24_69 VGND VGND VPWR VPWR sky130_fd_sc_hd__decap_3
XFILLER_10_237 VGND VGND VPWR VPWR sky130_fd_sc_hd__decap_3
XFILLER_10_259 VGND VGND VPWR VPWR sky130_fd_sc_hd__decap_3
X_6768_ _6929_/CLK _6768_/D VGND VGND VPWR VPWR _6768_/Q sky130_fd_sc_hd__dfxtp_2
XFILLER_109_626 VGND VGND VPWR VPWR sky130_fd_sc_hd__decap_3
XFILLER_40_35 VGND VGND VPWR VPWR sky130_fd_sc_hd__decap_3
X_6699_ _6975_/CLK _6699_/D VGND VGND VPWR VPWR _6699_/Q sky130_fd_sc_hd__dfxtp_2
X_5719_ _7365_/Q hold919/X _5719_/S VGND VGND VPWR VPWR _6709_/D sky130_fd_sc_hd__mux2_2
XFILLER_109_659 VGND VGND VPWR VPWR sky130_fd_sc_hd__decap_3
XFILLER_2_436 VGND VGND VPWR VPWR sky130_fd_sc_hd__decap_3
XFILLER_49_55 VGND VGND VPWR VPWR sky130_fd_sc_hd__fill_1
XFILLER_104_386 VGND VGND VPWR VPWR sky130_fd_sc_hd__decap_3
XFILLER_1_29 VGND VGND VPWR VPWR sky130_fd_sc_hd__decap_3
XFILLER_58_451 VGND VGND VPWR VPWR sky130_fd_sc_hd__fill_2
XFILLER_18_315 VGND VGND VPWR VPWR sky130_fd_sc_hd__decap_3
XFILLER_46_624 VGND VGND VPWR VPWR sky130_fd_sc_hd__decap_3
XFILLER_65_32 VGND VGND VPWR VPWR sky130_fd_sc_hd__decap_3
XFILLER_100_592 VGND VGND VPWR VPWR sky130_fd_sc_hd__decap_3
XFILLER_18_348 VGND VGND VPWR VPWR sky130_fd_sc_hd__decap_3
XFILLER_45_123 VGND VGND VPWR VPWR sky130_fd_sc_hd__decap_3
XFILLER_46_657 VGND VGND VPWR VPWR sky130_fd_sc_hd__decap_3
XFILLER_65_65 VGND VGND VPWR VPWR sky130_fd_sc_hd__decap_3
XFILLER_45_167 VGND VGND VPWR VPWR sky130_fd_sc_hd__fill_1
XFILLER_45_178 VGND VGND VPWR VPWR sky130_fd_sc_hd__decap_3
XFILLER_60_104 VGND VGND VPWR VPWR sky130_fd_sc_hd__decap_3
XFILLER_65_98 VGND VGND VPWR VPWR sky130_fd_sc_hd__decap_3
XFILLER_73_476 VGND VGND VPWR VPWR sky130_fd_sc_hd__decap_3
XFILLER_45_189 VGND VGND VPWR VPWR sky130_fd_sc_hd__decap_3
XFILLER_54_690 VGND VGND VPWR VPWR sky130_fd_sc_hd__fill_2
XFILLER_61_638 VGND VGND VPWR VPWR sky130_fd_sc_hd__decap_3
XFILLER_41_340 VGND VGND VPWR VPWR sky130_fd_sc_hd__decap_3
XFILLER_60_159 VGND VGND VPWR VPWR sky130_fd_sc_hd__fill_1
XTAP_TAPCELL_ROW_52_880 VGND VPWR sky130_fd_sc_hd__tapvpwrvgnd_1
XFILLER_14_80 VGND VGND VPWR VPWR sky130_fd_sc_hd__decap_3
XFILLER_108_681 VGND VGND VPWR VPWR sky130_fd_sc_hd__decap_3
XFILLER_114_106 VGND VGND VPWR VPWR sky130_fd_sc_hd__decap_3
XFILLER_115_629 VGND VGND VPWR VPWR sky130_fd_sc_hd__decap_3
XFILLER_114_139 VGND VGND VPWR VPWR sky130_fd_sc_hd__fill_1
XFILLER_46_6 VGND VGND VPWR VPWR sky130_fd_sc_hd__fill_1
XFILLER_110_312 VGND VGND VPWR VPWR sky130_fd_sc_hd__fill_2
XFILLER_110_323 VGND VGND VPWR VPWR sky130_fd_sc_hd__decap_3
XFILLER_110_334 VGND VGND VPWR VPWR sky130_fd_sc_hd__decap_3
XFILLER_96_579 VGND VGND VPWR VPWR sky130_fd_sc_hd__decap_3
X_4050_ _7053_/Q _4478_/S _4437_/B1 _7405_/Q _4049_/X VGND VGND VPWR VPWR _4050_/X
+ sky130_fd_sc_hd__a221o_2
XFILLER_110_378 VGND VGND VPWR VPWR sky130_fd_sc_hd__decap_3
XFILLER_37_613 VGND VGND VPWR VPWR sky130_fd_sc_hd__decap_3
XFILLER_64_410 VGND VGND VPWR VPWR sky130_fd_sc_hd__fill_2
XFILLER_37_668 VGND VGND VPWR VPWR sky130_fd_sc_hd__decap_3
XFILLER_64_421 VGND VGND VPWR VPWR sky130_fd_sc_hd__fill_1
XFILLER_76_292 VGND VGND VPWR VPWR sky130_fd_sc_hd__decap_3
XTAP_TAPCELL_ROW_108_1547 VGND VPWR sky130_fd_sc_hd__tapvpwrvgnd_1
XFILLER_36_145 VGND VGND VPWR VPWR sky130_fd_sc_hd__decap_3
XFILLER_52_616 VGND VGND VPWR VPWR sky130_fd_sc_hd__decap_3
XFILLER_17_370 VGND VGND VPWR VPWR sky130_fd_sc_hd__fill_1
XFILLER_64_498 VGND VGND VPWR VPWR sky130_fd_sc_hd__decap_3
XFILLER_91_273 VGND VGND VPWR VPWR sky130_fd_sc_hd__decap_3
XFILLER_91_284 VGND VGND VPWR VPWR sky130_fd_sc_hd__fill_1
X_4952_ _4967_/B _4968_/A VGND VGND VPWR VPWR _4969_/C sky130_fd_sc_hd__or2b_2
XFILLER_60_660 VGND VGND VPWR VPWR sky130_fd_sc_hd__decap_3
X_3903_ _6782_/Q _3926_/B1 _3925_/A2 _6692_/Q _3902_/X VGND VGND VPWR VPWR _3904_/B
+ sky130_fd_sc_hd__a221o_2
X_6622_ _6683_/A VGND VGND VPWR VPWR _6622_/Y sky130_fd_sc_hd__inv_2
XTAP_TAPCELL_ROW_22_519 VGND VPWR sky130_fd_sc_hd__tapvpwrvgnd_1
X_6553_ _6553_/A VGND VGND VPWR VPWR _6553_/Y sky130_fd_sc_hd__inv_2
X_3765_ _3629_/Y _3764_/X _4799_/A VGND VGND VPWR VPWR _4927_/B sky130_fd_sc_hd__o21a_2
X_6484_ _6642_/A VGND VGND VPWR VPWR _6484_/Y sky130_fd_sc_hd__inv_2
X_3696_ _6940_/Q _3902_/A2 _3759_/A2 _6804_/Q _3695_/X VGND VGND VPWR VPWR _3696_/X
+ sky130_fd_sc_hd__a221o_2
XFILLER_10_27 VGND VGND VPWR VPWR sky130_fd_sc_hd__fill_1
XFILLER_10_38 VGND VGND VPWR VPWR sky130_fd_sc_hd__decap_3
XFILLER_114_640 VGND VGND VPWR VPWR sky130_fd_sc_hd__decap_3
XFILLER_114_651 VGND VGND VPWR VPWR sky130_fd_sc_hd__decap_3
XFILLER_99_351 VGND VGND VPWR VPWR sky130_fd_sc_hd__decap_3
XFILLER_99_340 VGND VGND VPWR VPWR sky130_fd_sc_hd__fill_1
XFILLER_101_323 VGND VGND VPWR VPWR sky130_fd_sc_hd__decap_3
XFILLER_113_161 VGND VGND VPWR VPWR sky130_fd_sc_hd__decap_3
XFILLER_113_172 VGND VGND VPWR VPWR sky130_fd_sc_hd__decap_3
XFILLER_114_684 VGND VGND VPWR VPWR sky130_fd_sc_hd__decap_3
XFILLER_59_237 VGND VGND VPWR VPWR sky130_fd_sc_hd__decap_3
XFILLER_87_535 VGND VGND VPWR VPWR sky130_fd_sc_hd__decap_3
XFILLER_87_546 VGND VGND VPWR VPWR sky130_fd_sc_hd__decap_3
X_7105_ _7266_/CLK _7105_/D _6385_/Y VGND VGND VPWR VPWR _7105_/Q sky130_fd_sc_hd__dfrtp_2
X_4317_ _7322_/Q _4471_/S _4346_/B1 _7354_/Q _4248_/A VGND VGND VPWR VPWR _4317_/X
+ sky130_fd_sc_hd__a221o_2
XFILLER_99_384 VGND VGND VPWR VPWR sky130_fd_sc_hd__decap_3
XFILLER_19_14 VGND VGND VPWR VPWR sky130_fd_sc_hd__decap_3
XFILLER_19_47 VGND VGND VPWR VPWR sky130_fd_sc_hd__decap_3
X_7036_ _7386_/CLK _7036_/D _6316_/Y VGND VGND VPWR VPWR _7036_/Q sky130_fd_sc_hd__dfrtp_2
X_4248_ _4248_/A _4248_/B _4248_/C VGND VGND VPWR VPWR _4626_/B sky130_fd_sc_hd__or3_4
XFILLER_101_378 VGND VGND VPWR VPWR sky130_fd_sc_hd__decap_3
XFILLER_28_613 VGND VGND VPWR VPWR sky130_fd_sc_hd__decap_3
XTAP_TAPCELL_ROW_87_1300 VGND VPWR sky130_fd_sc_hd__tapvpwrvgnd_1
XFILLER_28_635 VGND VGND VPWR VPWR sky130_fd_sc_hd__decap_3
XFILLER_55_421 VGND VGND VPWR VPWR sky130_fd_sc_hd__decap_3
XFILLER_67_281 VGND VGND VPWR VPWR sky130_fd_sc_hd__decap_3
XFILLER_95_590 VGND VGND VPWR VPWR sky130_fd_sc_hd__decap_3
X_4179_ _4173_/Y _3388_/Y _4376_/A _4178_/Y VGND VGND VPWR VPWR _4186_/A sky130_fd_sc_hd__a211o_2
XFILLER_27_156 VGND VGND VPWR VPWR sky130_fd_sc_hd__decap_3
XFILLER_70_402 VGND VGND VPWR VPWR sky130_fd_sc_hd__fill_2
XFILLER_82_251 VGND VGND VPWR VPWR sky130_fd_sc_hd__fill_1
XFILLER_82_262 VGND VGND VPWR VPWR sky130_fd_sc_hd__decap_3
XTAP_TAPCELL_ROW_2_277 VGND VPWR sky130_fd_sc_hd__tapvpwrvgnd_1
XFILLER_27_178 VGND VGND VPWR VPWR sky130_fd_sc_hd__decap_3
XFILLER_35_35 VGND VGND VPWR VPWR sky130_fd_sc_hd__fill_2
XFILLER_35_57 VGND VGND VPWR VPWR sky130_fd_sc_hd__decap_3
XFILLER_36_690 VGND VGND VPWR VPWR sky130_fd_sc_hd__fill_2
XFILLER_43_638 VGND VGND VPWR VPWR sky130_fd_sc_hd__decap_3
XFILLER_55_487 VGND VGND VPWR VPWR sky130_fd_sc_hd__decap_3
XFILLER_70_457 VGND VGND VPWR VPWR sky130_fd_sc_hd__decap_3
XFILLER_51_671 VGND VGND VPWR VPWR sky130_fd_sc_hd__fill_1
XFILLER_51_682 VGND VGND VPWR VPWR sky130_fd_sc_hd__decap_3
XFILLER_51_45 VGND VGND VPWR VPWR sky130_fd_sc_hd__decap_3
Xclkbuf_3_3__f_clk clkbuf_0_clk/X VGND VGND VPWR VPWR clkload1/A sky130_fd_sc_hd__clkbuf_16
XPHY_EDGE_ROW_14_Right_14 VGND VGND VPWR VPWR sky130_fd_sc_hd__decap_3
XFILLER_11_579 VGND VGND VPWR VPWR sky130_fd_sc_hd__fill_1
XFILLER_51_67 VGND VGND VPWR VPWR sky130_fd_sc_hd__decap_3
XFILLER_109_434 VGND VGND VPWR VPWR sky130_fd_sc_hd__fill_2
XFILLER_109_445 VGND VGND VPWR VPWR sky130_fd_sc_hd__decap_3
XFILLER_109_467 VGND VGND VPWR VPWR sky130_fd_sc_hd__decap_3
XFILLER_2_222 VGND VGND VPWR VPWR sky130_fd_sc_hd__decap_3
XFILLER_105_640 VGND VGND VPWR VPWR sky130_fd_sc_hd__decap_3
XFILLER_105_673 VGND VGND VPWR VPWR sky130_fd_sc_hd__decap_3
XFILLER_78_513 VGND VGND VPWR VPWR sky130_fd_sc_hd__decap_3
XPHY_EDGE_ROW_23_Right_23 VGND VGND VPWR VPWR sky130_fd_sc_hd__decap_3
XFILLER_116_71 VGND VGND VPWR VPWR sky130_fd_sc_hd__decap_3
XFILLER_93_505 VGND VGND VPWR VPWR sky130_fd_sc_hd__decap_3
XFILLER_19_613 VGND VGND VPWR VPWR sky130_fd_sc_hd__decap_3
XFILLER_76_64 VGND VGND VPWR VPWR sky130_fd_sc_hd__decap_3
XFILLER_18_112 VGND VGND VPWR VPWR sky130_fd_sc_hd__fill_2
XFILLER_46_421 VGND VGND VPWR VPWR sky130_fd_sc_hd__fill_2
XFILLER_58_281 VGND VGND VPWR VPWR sky130_fd_sc_hd__decap_3
XFILLER_93_549 VGND VGND VPWR VPWR sky130_fd_sc_hd__fill_2
XFILLER_61_402 VGND VGND VPWR VPWR sky130_fd_sc_hd__decap_3
XFILLER_73_240 VGND VGND VPWR VPWR sky130_fd_sc_hd__decap_3
Xplace74 _5656_/C VGND VGND VPWR VPWR place74/X sky130_fd_sc_hd__buf_2
XFILLER_18_189 VGND VGND VPWR VPWR sky130_fd_sc_hd__decap_3
XFILLER_34_638 VGND VGND VPWR VPWR sky130_fd_sc_hd__decap_3
XFILLER_92_41 VGND VGND VPWR VPWR sky130_fd_sc_hd__decap_3
XFILLER_92_63 VGND VGND VPWR VPWR sky130_fd_sc_hd__decap_3
XFILLER_61_479 VGND VGND VPWR VPWR sky130_fd_sc_hd__decap_3
XFILLER_92_85 VGND VGND VPWR VPWR sky130_fd_sc_hd__decap_3
XPHY_EDGE_ROW_32_Right_32 VGND VGND VPWR VPWR sky130_fd_sc_hd__decap_3
XFILLER_25_90 VGND VGND VPWR VPWR sky130_fd_sc_hd__decap_3
XFILLER_42_660 VGND VGND VPWR VPWR sky130_fd_sc_hd__decap_3
XTAP_TAPCELL_ROW_103_1488 VGND VPWR sky130_fd_sc_hd__tapvpwrvgnd_1
X_3550_ _4614_/A _3547_/A _3547_/B _3548_/X VGND VGND VPWR VPWR _3550_/X sky130_fd_sc_hd__a31o_2
X_3481_ _7344_/Q _4337_/B _5126_/S _7280_/Q VGND VGND VPWR VPWR _3482_/C sky130_fd_sc_hd__a22o_2
XFILLER_102_109 VGND VGND VPWR VPWR sky130_fd_sc_hd__decap_3
XFILLER_44_3 VGND VGND VPWR VPWR sky130_fd_sc_hd__decap_3
XTAP_TAPCELL_ROW_71_1101 VGND VPWR sky130_fd_sc_hd__tapvpwrvgnd_1
XPHY_EDGE_ROW_41_Right_41 VGND VGND VPWR VPWR sky130_fd_sc_hd__decap_3
XFILLER_69_535 VGND VGND VPWR VPWR sky130_fd_sc_hd__decap_3
XFILLER_96_321 VGND VGND VPWR VPWR sky130_fd_sc_hd__decap_3
X_5151_ _5151_/A _5659_/B VGND VGND VPWR VPWR _5151_/X sky130_fd_sc_hd__or2_2
XFILLER_111_632 VGND VGND VPWR VPWR sky130_fd_sc_hd__decap_3
XFILLER_111_665 VGND VGND VPWR VPWR sky130_fd_sc_hd__decap_3
XFILLER_96_332 VGND VGND VPWR VPWR sky130_fd_sc_hd__decap_3
X_5082_ _6986_/Q _5098_/A VGND VGND VPWR VPWR _6986_/D sky130_fd_sc_hd__xor2_2
X_4102_ _7077_/Q _4265_/B VGND VGND VPWR VPWR _4141_/B sky130_fd_sc_hd__nor2_2
XFILLER_111_676 VGND VGND VPWR VPWR sky130_fd_sc_hd__decap_3
XFILLER_2_50 VGND VGND VPWR VPWR sky130_fd_sc_hd__decap_3
XFILLER_84_527 VGND VGND VPWR VPWR sky130_fd_sc_hd__decap_3
XFILLER_96_365 VGND VGND VPWR VPWR sky130_fd_sc_hd__decap_3
X_4033_ _7054_/Q _4478_/S _4437_/B1 _7406_/Q VGND VGND VPWR VPWR _4033_/X sky130_fd_sc_hd__a22o_2
XFILLER_110_197 VGND VGND VPWR VPWR sky130_fd_sc_hd__decap_3
XFILLER_2_83 VGND VGND VPWR VPWR sky130_fd_sc_hd__fill_1
XFILLER_2_94 VGND VGND VPWR VPWR sky130_fd_sc_hd__decap_3
XFILLER_37_421 VGND VGND VPWR VPWR sky130_fd_sc_hd__decap_3
XFILLER_49_270 VGND VGND VPWR VPWR sky130_fd_sc_hd__decap_3
XFILLER_49_281 VGND VGND VPWR VPWR sky130_fd_sc_hd__decap_3
XFILLER_112_29 VGND VGND VPWR VPWR sky130_fd_sc_hd__decap_3
XFILLER_52_402 VGND VGND VPWR VPWR sky130_fd_sc_hd__decap_3
XTAP_TAPCELL_ROW_55_909 VGND VPWR sky130_fd_sc_hd__tapvpwrvgnd_1
XFILLER_37_487 VGND VGND VPWR VPWR sky130_fd_sc_hd__decap_3
XFILLER_37_498 VGND VGND VPWR VPWR sky130_fd_sc_hd__decap_3
XFILLER_52_424 VGND VGND VPWR VPWR sky130_fd_sc_hd__decap_3
XFILLER_64_284 VGND VGND VPWR VPWR sky130_fd_sc_hd__fill_2
XFILLER_92_582 VGND VGND VPWR VPWR sky130_fd_sc_hd__decap_3
XTAP_TAPCELL_ROW_69_1085 VGND VPWR sky130_fd_sc_hd__tapvpwrvgnd_1
XTAP_TAPCELL_ROW_69_1074 VGND VPWR sky130_fd_sc_hd__tapvpwrvgnd_1
XPHY_EDGE_ROW_50_Right_50 VGND VGND VPWR VPWR sky130_fd_sc_hd__decap_3
XFILLER_24_137 VGND VGND VPWR VPWR sky130_fd_sc_hd__decap_3
XFILLER_24_159 VGND VGND VPWR VPWR sky130_fd_sc_hd__fill_2
XTAP_TAPCELL_ROW_82_1241 VGND VPWR sky130_fd_sc_hd__tapvpwrvgnd_1
XTAP_TAPCELL_ROW_82_1230 VGND VPWR sky130_fd_sc_hd__tapvpwrvgnd_1
XFILLER_33_682 VGND VGND VPWR VPWR sky130_fd_sc_hd__fill_2
X_4935_ _6995_/Q _4963_/A VGND VGND VPWR VPWR _6995_/D sky130_fd_sc_hd__xor2_2
XTAP_TAPCELL_ROW_35_677 VGND VPWR sky130_fd_sc_hd__tapvpwrvgnd_1
XTAP_TAPCELL_ROW_35_666 VGND VPWR sky130_fd_sc_hd__tapvpwrvgnd_1
XFILLER_32_170 VGND VGND VPWR VPWR sky130_fd_sc_hd__decap_3
X_6605_ _6638_/A VGND VGND VPWR VPWR _6605_/Y sky130_fd_sc_hd__inv_2
X_4797_ _3526_/B _4648_/A _4795_/A _5033_/B2 VGND VGND VPWR VPWR _4797_/X sky130_fd_sc_hd__a22o_2
X_3817_ _3682_/A _3816_/X _5104_/A VGND VGND VPWR VPWR _3817_/X sky130_fd_sc_hd__a21o_2
XFILLER_21_15 VGND VGND VPWR VPWR sky130_fd_sc_hd__decap_3
X_6536_ _6536_/A VGND VGND VPWR VPWR _6536_/Y sky130_fd_sc_hd__inv_2
X_3748_ _3735_/X _3738_/X _3740_/X _3923_/A1 _3747_/X VGND VGND VPWR VPWR _3748_/X
+ sky130_fd_sc_hd__a221o_2
XFILLER_106_437 VGND VGND VPWR VPWR sky130_fd_sc_hd__decap_3
X_6467_ _6635_/A VGND VGND VPWR VPWR _6467_/Y sky130_fd_sc_hd__inv_2
X_3679_ _6894_/Q VGND VGND VPWR VPWR _3679_/Y sky130_fd_sc_hd__inv_2
XFILLER_106_459 VGND VGND VPWR VPWR sky130_fd_sc_hd__decap_3
X_6398_ _6647_/A VGND VGND VPWR VPWR _6398_/Y sky130_fd_sc_hd__inv_2
XTAP_TAPCELL_ROW_93_1370 VGND VPWR sky130_fd_sc_hd__tapvpwrvgnd_1
XFILLER_102_610 VGND VGND VPWR VPWR sky130_fd_sc_hd__decap_3
XTAP_TAPCELL_ROW_7_336 VGND VPWR sky130_fd_sc_hd__tapvpwrvgnd_1
XFILLER_102_643 VGND VGND VPWR VPWR sky130_fd_sc_hd__fill_1
XFILLER_102_654 VGND VGND VPWR VPWR sky130_fd_sc_hd__decap_3
XFILLER_114_492 VGND VGND VPWR VPWR sky130_fd_sc_hd__decap_3
XFILLER_87_332 VGND VGND VPWR VPWR sky130_fd_sc_hd__decap_3
XFILLER_102_687 VGND VGND VPWR VPWR sky130_fd_sc_hd__decap_3
XFILLER_87_365 VGND VGND VPWR VPWR sky130_fd_sc_hd__decap_3
XFILLER_101_175 VGND VGND VPWR VPWR sky130_fd_sc_hd__fill_2
XFILLER_75_538 VGND VGND VPWR VPWR sky130_fd_sc_hd__decap_3
X_7019_ _7267_/CLK _7019_/D _6299_/Y VGND VGND VPWR VPWR _7019_/Q sky130_fd_sc_hd__dfrtp_2
XFILLER_46_56 VGND VGND VPWR VPWR sky130_fd_sc_hd__decap_3
XFILLER_55_251 VGND VGND VPWR VPWR sky130_fd_sc_hd__decap_3
XFILLER_46_78 VGND VGND VPWR VPWR sky130_fd_sc_hd__decap_3
XFILLER_55_284 VGND VGND VPWR VPWR sky130_fd_sc_hd__decap_3
XFILLER_102_73 VGND VGND VPWR VPWR sky130_fd_sc_hd__decap_3
XFILLER_15_159 VGND VGND VPWR VPWR sky130_fd_sc_hd__fill_2
XFILLER_70_243 VGND VGND VPWR VPWR sky130_fd_sc_hd__decap_3
XFILLER_62_44 VGND VGND VPWR VPWR sky130_fd_sc_hd__decap_3
XFILLER_70_265 VGND VGND VPWR VPWR sky130_fd_sc_hd__decap_3
XFILLER_11_332 VGND VGND VPWR VPWR sky130_fd_sc_hd__decap_3
XFILLER_23_181 VGND VGND VPWR VPWR sky130_fd_sc_hd__decap_3
XFILLER_51_490 VGND VGND VPWR VPWR sky130_fd_sc_hd__decap_3
XFILLER_62_77 VGND VGND VPWR VPWR sky130_fd_sc_hd__decap_3
XFILLER_62_88 VGND VGND VPWR VPWR sky130_fd_sc_hd__decap_3
XFILLER_109_220 VGND VGND VPWR VPWR sky130_fd_sc_hd__decap_3
XFILLER_109_231 VGND VGND VPWR VPWR sky130_fd_sc_hd__fill_2
XFILLER_7_39 VGND VGND VPWR VPWR sky130_fd_sc_hd__decap_3
XFILLER_3_531 VGND VGND VPWR VPWR sky130_fd_sc_hd__fill_1
XFILLER_98_619 VGND VGND VPWR VPWR sky130_fd_sc_hd__fill_1
XFILLER_87_30 VGND VGND VPWR VPWR sky130_fd_sc_hd__decap_3
XFILLER_78_321 VGND VGND VPWR VPWR sky130_fd_sc_hd__decap_3
XFILLER_87_74 VGND VGND VPWR VPWR sky130_fd_sc_hd__fill_1
XFILLER_38_218 VGND VGND VPWR VPWR sky130_fd_sc_hd__fill_1
XFILLER_78_365 VGND VGND VPWR VPWR sky130_fd_sc_hd__decap_3
XFILLER_87_96 VGND VGND VPWR VPWR sky130_fd_sc_hd__decap_3
XFILLER_38_229 VGND VGND VPWR VPWR sky130_fd_sc_hd__decap_3
XFILLER_93_346 VGND VGND VPWR VPWR sky130_fd_sc_hd__decap_3
XFILLER_46_251 VGND VGND VPWR VPWR sky130_fd_sc_hd__fill_1
XFILLER_81_508 VGND VGND VPWR VPWR sky130_fd_sc_hd__decap_3
XFILLER_34_424 VGND VGND VPWR VPWR sky130_fd_sc_hd__decap_3
XTAP_TAPCELL_ROW_105_1517 VGND VPWR sky130_fd_sc_hd__tapvpwrvgnd_1
XTAP_TAPCELL_ROW_105_1506 VGND VPWR sky130_fd_sc_hd__tapvpwrvgnd_1
XFILLER_61_243 VGND VGND VPWR VPWR sky130_fd_sc_hd__decap_3
XFILLER_61_276 VGND VGND VPWR VPWR sky130_fd_sc_hd__decap_3
XFILLER_61_287 VGND VGND VPWR VPWR sky130_fd_sc_hd__decap_3
XFILLER_14_170 VGND VGND VPWR VPWR sky130_fd_sc_hd__decap_3
Xclkbuf_leaf_41_clk clkbuf_3_0__f_clk/X VGND VGND VPWR VPWR clkload6/A sky130_fd_sc_hd__clkbuf_16
X_4720_ _4720_/A _4720_/B VGND VGND VPWR VPWR _4720_/X sky130_fd_sc_hd__xor2_2
XTAP_TAPCELL_ROW_32_636 VGND VPWR sky130_fd_sc_hd__tapvpwrvgnd_1
X_4651_ _4813_/A _4810_/B VGND VGND VPWR VPWR _4652_/B sky130_fd_sc_hd__and2_2
XTAP_TAPCELL_ROW_60_967 VGND VPWR sky130_fd_sc_hd__tapvpwrvgnd_1
X_3602_ _4614_/A _3547_/A _3547_/B _4614_/C _4613_/B VGND VGND VPWR VPWR _3603_/B
+ sky130_fd_sc_hd__a41o_2
X_7370_ _7403_/CLK _7370_/D _6650_/Y VGND VGND VPWR VPWR _7370_/Q sky130_fd_sc_hd__dfrtp_2
XTAP_TAPCELL_ROW_12_393 VGND VPWR sky130_fd_sc_hd__tapvpwrvgnd_1
XFILLER_115_223 VGND VGND VPWR VPWR sky130_fd_sc_hd__fill_1
Xhold804 _6775_/Q VGND VGND VPWR VPWR _6775_/D sky130_fd_sc_hd__dlygate4sd3_1
Xhold815 _6765_/Q VGND VGND VPWR VPWR _6765_/D sky130_fd_sc_hd__dlygate4sd3_1
Xhold826 _6801_/Q VGND VGND VPWR VPWR _6801_/D sky130_fd_sc_hd__dlygate4sd3_1
Xhold837 _6751_/Q VGND VGND VPWR VPWR _6751_/D sky130_fd_sc_hd__dlygate4sd3_1
X_6321_ _6674_/A VGND VGND VPWR VPWR _6321_/Y sky130_fd_sc_hd__inv_2
XTAP_TAPCELL_ROW_116_1657 VGND VPWR sky130_fd_sc_hd__tapvpwrvgnd_1
XTAP_TAPCELL_ROW_116_1646 VGND VPWR sky130_fd_sc_hd__tapvpwrvgnd_1
XFILLER_107_29 VGND VGND VPWR VPWR sky130_fd_sc_hd__decap_3
XFILLER_115_234 VGND VGND VPWR VPWR sky130_fd_sc_hd__decap_3
Xhold848 _7103_/Q VGND VGND VPWR VPWR _7103_/D sky130_fd_sc_hd__dlygate4sd3_1
Xhold859 _7084_/Q VGND VGND VPWR VPWR _7084_/D sky130_fd_sc_hd__dlygate4sd3_1
Xmax_cap556 _4619_/Y VGND VGND VPWR VPWR _4625_/A2 sky130_fd_sc_hd__buf_1
XFILLER_115_278 VGND VGND VPWR VPWR sky130_fd_sc_hd__fill_2
XFILLER_88_129 VGND VGND VPWR VPWR sky130_fd_sc_hd__decap_3
X_5203_ _5203_/A _5225_/B VGND VGND VPWR VPWR _7227_/D sky130_fd_sc_hd__and2_2
XFILLER_69_343 VGND VGND VPWR VPWR sky130_fd_sc_hd__decap_3
XFILLER_97_641 VGND VGND VPWR VPWR sky130_fd_sc_hd__fill_1
X_5134_ _3735_/A _3908_/X _3346_/A VGND VGND VPWR VPWR _5134_/X sky130_fd_sc_hd__o21a_2
X_3395_ _7059_/Q _3577_/B VGND VGND VPWR VPWR _3589_/B sky130_fd_sc_hd__nor2_2
XFILLER_57_505 VGND VGND VPWR VPWR sky130_fd_sc_hd__decap_3
XFILLER_97_663 VGND VGND VPWR VPWR sky130_fd_sc_hd__decap_3
XFILLER_97_685 VGND VGND VPWR VPWR sky130_fd_sc_hd__decap_3
XFILLER_111_495 VGND VGND VPWR VPWR sky130_fd_sc_hd__decap_3
XFILLER_96_184 VGND VGND VPWR VPWR sky130_fd_sc_hd__decap_3
X_5065_ _6986_/Q _5098_/A _6987_/Q VGND VGND VPWR VPWR _5066_/B sky130_fd_sc_hd__a21oi_2
XFILLER_37_251 VGND VGND VPWR VPWR sky130_fd_sc_hd__decap_3
XFILLER_84_368 VGND VGND VPWR VPWR sky130_fd_sc_hd__decap_3
XFILLER_16_15 VGND VGND VPWR VPWR sky130_fd_sc_hd__decap_3
XFILLER_25_402 VGND VGND VPWR VPWR sky130_fd_sc_hd__fill_1
XFILLER_16_59 VGND VGND VPWR VPWR sky130_fd_sc_hd__decap_3
XFILLER_52_221 VGND VGND VPWR VPWR sky130_fd_sc_hd__decap_3
XFILLER_80_530 VGND VGND VPWR VPWR sky130_fd_sc_hd__fill_2
XFILLER_52_265 VGND VGND VPWR VPWR sky130_fd_sc_hd__decap_3
XFILLER_80_563 VGND VGND VPWR VPWR sky130_fd_sc_hd__decap_3
XFILLER_40_449 VGND VGND VPWR VPWR sky130_fd_sc_hd__decap_3
XFILLER_52_298 VGND VGND VPWR VPWR sky130_fd_sc_hd__decap_3
Xclkbuf_leaf_32_clk clkbuf_3_2__f_clk/X VGND VGND VPWR VPWR _6977_/CLK sky130_fd_sc_hd__clkbuf_16
X_4918_ _4918_/A _4918_/B VGND VGND VPWR VPWR _4936_/B sky130_fd_sc_hd__nor2_2
XFILLER_32_47 VGND VGND VPWR VPWR sky130_fd_sc_hd__decap_3
XFILLER_20_162 VGND VGND VPWR VPWR sky130_fd_sc_hd__decap_3
X_4849_ _4872_/A _4872_/B VGND VGND VPWR VPWR _4849_/Y sky130_fd_sc_hd__nor2_2
XFILLER_106_223 VGND VGND VPWR VPWR sky130_fd_sc_hd__decap_3
XFILLER_113_6 VGND VGND VPWR VPWR sky130_fd_sc_hd__decap_3
X_6519_ _6553_/A VGND VGND VPWR VPWR _6519_/Y sky130_fd_sc_hd__inv_2
XFILLER_0_578 VGND VGND VPWR VPWR sky130_fd_sc_hd__decap_3
XFILLER_102_462 VGND VGND VPWR VPWR sky130_fd_sc_hd__decap_3
XFILLER_57_33 VGND VGND VPWR VPWR sky130_fd_sc_hd__decap_3
XFILLER_87_140 VGND VGND VPWR VPWR sky130_fd_sc_hd__decap_3
XFILLER_88_663 VGND VGND VPWR VPWR sky130_fd_sc_hd__decap_3
XFILLER_102_495 VGND VGND VPWR VPWR sky130_fd_sc_hd__decap_3
XFILLER_57_66 VGND VGND VPWR VPWR sky130_fd_sc_hd__decap_3
XFILLER_28_240 VGND VGND VPWR VPWR sky130_fd_sc_hd__decap_3
XFILLER_57_99 VGND VGND VPWR VPWR sky130_fd_sc_hd__decap_3
XFILLER_113_72 VGND VGND VPWR VPWR sky130_fd_sc_hd__decap_3
XFILLER_28_262 VGND VGND VPWR VPWR sky130_fd_sc_hd__decap_3
XFILLER_43_210 VGND VGND VPWR VPWR sky130_fd_sc_hd__fill_1
XFILLER_43_254 VGND VGND VPWR VPWR sky130_fd_sc_hd__decap_3
XFILLER_71_585 VGND VGND VPWR VPWR sky130_fd_sc_hd__decap_3
XFILLER_12_630 VGND VGND VPWR VPWR sky130_fd_sc_hd__decap_3
Xclkbuf_leaf_23_clk clkload1/A VGND VGND VPWR VPWR _6965_/CLK sky130_fd_sc_hd__clkbuf_16
XTAP_TAPCELL_ROW_100_1447 VGND VPWR sky130_fd_sc_hd__tapvpwrvgnd_1
XFILLER_7_111 VGND VGND VPWR VPWR sky130_fd_sc_hd__fill_1
XFILLER_7_122 VGND VGND VPWR VPWR sky130_fd_sc_hd__decap_3
XFILLER_7_155 VGND VGND VPWR VPWR sky130_fd_sc_hd__decap_3
XFILLER_22_80 VGND VGND VPWR VPWR sky130_fd_sc_hd__decap_3
XFILLER_22_91 VGND VGND VPWR VPWR sky130_fd_sc_hd__decap_3
XFILLER_98_51 VGND VGND VPWR VPWR sky130_fd_sc_hd__decap_3
XFILLER_112_215 VGND VGND VPWR VPWR sky130_fd_sc_hd__decap_3
XFILLER_3_372 VGND VGND VPWR VPWR sky130_fd_sc_hd__decap_3
XFILLER_98_416 VGND VGND VPWR VPWR sky130_fd_sc_hd__decap_3
XFILLER_79_641 VGND VGND VPWR VPWR sky130_fd_sc_hd__decap_3
XFILLER_39_505 VGND VGND VPWR VPWR sky130_fd_sc_hd__decap_3
XFILLER_78_162 VGND VGND VPWR VPWR sky130_fd_sc_hd__fill_1
XFILLER_79_685 VGND VGND VPWR VPWR sky130_fd_sc_hd__decap_3
XTAP_TAPCELL_ROW_111_1587 VGND VPWR sky130_fd_sc_hd__tapvpwrvgnd_1
XFILLER_78_195 VGND VGND VPWR VPWR sky130_fd_sc_hd__fill_1
XFILLER_66_368 VGND VGND VPWR VPWR sky130_fd_sc_hd__fill_1
XFILLER_94_666 VGND VGND VPWR VPWR sky130_fd_sc_hd__decap_3
XFILLER_19_262 VGND VGND VPWR VPWR sky130_fd_sc_hd__decap_3
XFILLER_19_284 VGND VGND VPWR VPWR sky130_fd_sc_hd__decap_3
XFILLER_93_165 VGND VGND VPWR VPWR sky130_fd_sc_hd__decap_3
XFILLER_34_221 VGND VGND VPWR VPWR sky130_fd_sc_hd__decap_3
XFILLER_81_349 VGND VGND VPWR VPWR sky130_fd_sc_hd__decap_3
X_6870_ _6931_/CLK _6870_/D VGND VGND VPWR VPWR _6870_/Q sky130_fd_sc_hd__dfxtp_2
XTAP_TAPCELL_ROW_66_1044 VGND VPWR sky130_fd_sc_hd__tapvpwrvgnd_1
XFILLER_34_265 VGND VGND VPWR VPWR sky130_fd_sc_hd__decap_3
XFILLER_62_563 VGND VGND VPWR VPWR sky130_fd_sc_hd__decap_3
XTAP_TAPCELL_ROW_17_452 VGND VPWR sky130_fd_sc_hd__tapvpwrvgnd_1
XFILLER_22_427 VGND VGND VPWR VPWR sky130_fd_sc_hd__decap_3
XTAP_TAPCELL_ROW_45_794 VGND VPWR sky130_fd_sc_hd__tapvpwrvgnd_1
Xclkbuf_leaf_14_clk clkload3/A VGND VGND VPWR VPWR _7369_/CLK sky130_fd_sc_hd__clkbuf_16
X_4703_ _6992_/Q _6993_/Q _5001_/A VGND VGND VPWR VPWR _4977_/A sky130_fd_sc_hd__and3_2
XFILLER_30_471 VGND VGND VPWR VPWR sky130_fd_sc_hd__decap_3
XFILLER_8_71 VGND VGND VPWR VPWR sky130_fd_sc_hd__decap_3
X_4634_ _4937_/A _4920_/A _4967_/B _4950_/A VGND VGND VPWR VPWR _4634_/Y sky130_fd_sc_hd__nand4bb_2
X_7353_ _7386_/CLK _7353_/D _6633_/Y VGND VGND VPWR VPWR _7353_/Q sky130_fd_sc_hd__dfrtp_2
Xhold601 _6915_/Q VGND VGND VPWR VPWR _6915_/D sky130_fd_sc_hd__dlygate4sd3_1
Xhold612 _6934_/Q VGND VGND VPWR VPWR _6934_/D sky130_fd_sc_hd__dlygate4sd3_1
X_4565_ _4565_/A _4567_/B VGND VGND VPWR VPWR _7298_/D sky130_fd_sc_hd__and2_2
XFILLER_116_554 VGND VGND VPWR VPWR sky130_fd_sc_hd__decap_3
XFILLER_89_405 VGND VGND VPWR VPWR sky130_fd_sc_hd__decap_3
Xhold623 _6758_/Q VGND VGND VPWR VPWR _6758_/D sky130_fd_sc_hd__dlygate4sd3_1
Xhold634 _6834_/Q VGND VGND VPWR VPWR _6834_/D sky130_fd_sc_hd__dlygate4sd3_1
Xhold645 _6729_/Q VGND VGND VPWR VPWR _6729_/D sky130_fd_sc_hd__dlygate4sd3_1
X_6304_ _6553_/A VGND VGND VPWR VPWR _6304_/Y sky130_fd_sc_hd__inv_2
X_3516_ _5118_/A _3362_/A _5118_/D _3369_/A VGND VGND VPWR VPWR _3516_/X sky130_fd_sc_hd__a211o_2
XTAP_TAPCELL_ROW_77_1173 VGND VPWR sky130_fd_sc_hd__tapvpwrvgnd_1
X_7284_ clkload5/A _7284_/D _6564_/Y VGND VGND VPWR VPWR _7284_/Q sky130_fd_sc_hd__dfrtp_2
Xhold656 _6770_/Q VGND VGND VPWR VPWR _6770_/D sky130_fd_sc_hd__dlygate4sd3_1
Xhold667 _6790_/Q VGND VGND VPWR VPWR _6790_/D sky130_fd_sc_hd__dlygate4sd3_1
Xhold678 _6870_/Q VGND VGND VPWR VPWR _6870_/D sky130_fd_sc_hd__dlygate4sd3_1
XPHY_EDGE_ROW_4_Right_4 VGND VGND VPWR VPWR sky130_fd_sc_hd__decap_3
XFILLER_103_248 VGND VGND VPWR VPWR sky130_fd_sc_hd__decap_3
Xhold689 _6722_/Q VGND VGND VPWR VPWR _6722_/D sky130_fd_sc_hd__dlygate4sd3_1
X_3447_ _7090_/Q _4321_/A2 _3407_/X _7122_/Q VGND VGND VPWR VPWR _3447_/X sky130_fd_sc_hd__a22o_2
XFILLER_85_600 VGND VGND VPWR VPWR sky130_fd_sc_hd__decap_3
XFILLER_85_611 VGND VGND VPWR VPWR sky130_fd_sc_hd__decap_3
XFILLER_97_460 VGND VGND VPWR VPWR sky130_fd_sc_hd__decap_3
X_3378_ _3378_/A _5646_/A VGND VGND VPWR VPWR _3378_/Y sky130_fd_sc_hd__nor2_2
XFILLER_111_281 VGND VGND VPWR VPWR sky130_fd_sc_hd__decap_3
XFILLER_57_324 VGND VGND VPWR VPWR sky130_fd_sc_hd__decap_3
XFILLER_84_110 VGND VGND VPWR VPWR sky130_fd_sc_hd__decap_3
XFILLER_97_482 VGND VGND VPWR VPWR sky130_fd_sc_hd__decap_3
X_5117_ _5595_/B _5117_/B _3896_/Y VGND VGND VPWR VPWR _5117_/X sky130_fd_sc_hd__or3b_2
XFILLER_27_25 VGND VGND VPWR VPWR sky130_fd_sc_hd__decap_3
XFILLER_45_508 VGND VGND VPWR VPWR sky130_fd_sc_hd__decap_3
XFILLER_85_655 VGND VGND VPWR VPWR sky130_fd_sc_hd__decap_3
X_5048_ _5086_/A _5084_/B _4621_/X VGND VGND VPWR VPWR _5073_/B sky130_fd_sc_hd__o21bai_2
XFILLER_38_582 VGND VGND VPWR VPWR sky130_fd_sc_hd__decap_3
XFILLER_72_305 VGND VGND VPWR VPWR sky130_fd_sc_hd__decap_3
XFILLER_72_327 VGND VGND VPWR VPWR sky130_fd_sc_hd__fill_1
XFILLER_84_176 VGND VGND VPWR VPWR sky130_fd_sc_hd__decap_3
XFILLER_85_688 VGND VGND VPWR VPWR sky130_fd_sc_hd__decap_3
XFILLER_25_265 VGND VGND VPWR VPWR sky130_fd_sc_hd__fill_1
XFILLER_13_427 VGND VGND VPWR VPWR sky130_fd_sc_hd__decap_3
XFILLER_13_449 VGND VGND VPWR VPWR sky130_fd_sc_hd__decap_3
XFILLER_25_298 VGND VGND VPWR VPWR sky130_fd_sc_hd__fill_2
XFILLER_40_235 VGND VGND VPWR VPWR sky130_fd_sc_hd__decap_3
X_6999_ _7372_/CLK _6999_/D _6279_/Y VGND VGND VPWR VPWR _6999_/Q sky130_fd_sc_hd__dfrtp_2
XFILLER_43_57 VGND VGND VPWR VPWR sky130_fd_sc_hd__decap_3
XFILLER_21_471 VGND VGND VPWR VPWR sky130_fd_sc_hd__fill_1
XFILLER_40_279 VGND VGND VPWR VPWR sky130_fd_sc_hd__decap_3
XFILLER_111_3 VGND VGND VPWR VPWR sky130_fd_sc_hd__decap_3
XFILLER_4_103 VGND VGND VPWR VPWR sky130_fd_sc_hd__decap_3
XFILLER_5_637 VGND VGND VPWR VPWR sky130_fd_sc_hd__decap_3
XFILLER_4_136 VGND VGND VPWR VPWR sky130_fd_sc_hd__decap_3
XFILLER_4_147 VGND VGND VPWR VPWR sky130_fd_sc_hd__decap_3
XFILLER_107_598 VGND VGND VPWR VPWR sky130_fd_sc_hd__decap_3
XFILLER_108_50 VGND VGND VPWR VPWR sky130_fd_sc_hd__decap_3
XFILLER_4_18 VGND VGND VPWR VPWR sky130_fd_sc_hd__decap_3
XFILLER_4_29 VGND VGND VPWR VPWR sky130_fd_sc_hd__decap_3
XFILLER_108_83 VGND VGND VPWR VPWR sky130_fd_sc_hd__fill_1
XFILLER_108_94 VGND VGND VPWR VPWR sky130_fd_sc_hd__fill_2
XFILLER_68_32 VGND VGND VPWR VPWR sky130_fd_sc_hd__decap_3
XFILLER_68_54 VGND VGND VPWR VPWR sky130_fd_sc_hd__decap_3
XFILLER_95_419 VGND VGND VPWR VPWR sky130_fd_sc_hd__decap_3
XFILLER_76_622 VGND VGND VPWR VPWR sky130_fd_sc_hd__decap_3
XFILLER_48_368 VGND VGND VPWR VPWR sky130_fd_sc_hd__fill_1
XFILLER_76_655 VGND VGND VPWR VPWR sky130_fd_sc_hd__fill_1
XFILLER_76_666 VGND VGND VPWR VPWR sky130_fd_sc_hd__decap_3
XFILLER_84_20 VGND VGND VPWR VPWR sky130_fd_sc_hd__fill_1
XFILLER_63_316 VGND VGND VPWR VPWR sky130_fd_sc_hd__decap_3
XFILLER_63_327 VGND VGND VPWR VPWR sky130_fd_sc_hd__decap_3
XFILLER_75_187 VGND VGND VPWR VPWR sky130_fd_sc_hd__fill_1
XFILLER_84_53 VGND VGND VPWR VPWR sky130_fd_sc_hd__decap_3
XFILLER_63_349 VGND VGND VPWR VPWR sky130_fd_sc_hd__decap_3
XFILLER_91_658 VGND VGND VPWR VPWR sky130_fd_sc_hd__decap_3
Xplace327 _5737_/S VGND VGND VPWR VPWR _5719_/S sky130_fd_sc_hd__buf_2
Xplace316 _4327_/A VGND VGND VPWR VPWR _4425_/A sky130_fd_sc_hd__buf_2
Xplace305 _3618_/X VGND VGND VPWR VPWR _4969_/B sky130_fd_sc_hd__buf_2
Xplace349 _4321_/A2 VGND VGND VPWR VPWR _4351_/A2 sky130_fd_sc_hd__buf_2
Xplace338 _5417_/S VGND VGND VPWR VPWR _5429_/S sky130_fd_sc_hd__buf_2
XFILLER_16_276 VGND VGND VPWR VPWR sky130_fd_sc_hd__decap_3
XFILLER_31_202 VGND VGND VPWR VPWR sky130_fd_sc_hd__decap_3
XFILLER_31_235 VGND VGND VPWR VPWR sky130_fd_sc_hd__decap_3
XFILLER_71_382 VGND VGND VPWR VPWR sky130_fd_sc_hd__decap_3
XFILLER_71_393 VGND VGND VPWR VPWR sky130_fd_sc_hd__decap_3
XTAP_TAPCELL_ROW_14_422 VGND VPWR sky130_fd_sc_hd__tapvpwrvgnd_1
XFILLER_31_268 VGND VGND VPWR VPWR sky130_fd_sc_hd__decap_3
XTAP_TAPCELL_ROW_42_753 VGND VPWR sky130_fd_sc_hd__tapvpwrvgnd_1
XFILLER_33_90 VGND VGND VPWR VPWR sky130_fd_sc_hd__decap_3
XFILLER_8_475 VGND VGND VPWR VPWR sky130_fd_sc_hd__fill_1
X_4350_ _7065_/Q _4265_/B _4460_/A VGND VGND VPWR VPWR _4367_/B sky130_fd_sc_hd__o21a_2
XTAP_TAPCELL_ROW_113_1605 VGND VPWR sky130_fd_sc_hd__tapvpwrvgnd_1
X_3301_ _6981_/Q _6980_/Q VGND VGND VPWR VPWR _3519_/B sky130_fd_sc_hd__nand2_4
XFILLER_4_681 VGND VGND VPWR VPWR sky130_fd_sc_hd__decap_3
X_4281_ _7254_/Q _3358_/X _4278_/X _4280_/X VGND VGND VPWR VPWR _4281_/X sky130_fd_sc_hd__a211o_2
XFILLER_98_235 VGND VGND VPWR VPWR sky130_fd_sc_hd__fill_1
Xclkbuf_leaf_3_clk clkbuf_leaf_4_clk/A VGND VGND VPWR VPWR _7264_/CLK sky130_fd_sc_hd__clkbuf_16
XFILLER_100_218 VGND VGND VPWR VPWR sky130_fd_sc_hd__decap_3
XFILLER_39_313 VGND VGND VPWR VPWR sky130_fd_sc_hd__fill_2
XFILLER_79_471 VGND VGND VPWR VPWR sky130_fd_sc_hd__decap_3
XFILLER_79_493 VGND VGND VPWR VPWR sky130_fd_sc_hd__decap_3
XFILLER_39_357 VGND VGND VPWR VPWR sky130_fd_sc_hd__fill_1
XFILLER_66_132 VGND VGND VPWR VPWR sky130_fd_sc_hd__decap_3
XFILLER_67_655 VGND VGND VPWR VPWR sky130_fd_sc_hd__decap_3
XFILLER_94_463 VGND VGND VPWR VPWR sky130_fd_sc_hd__decap_3
XFILLER_39_379 VGND VGND VPWR VPWR sky130_fd_sc_hd__fill_2
XFILLER_54_327 VGND VGND VPWR VPWR sky130_fd_sc_hd__decap_3
XFILLER_66_187 VGND VGND VPWR VPWR sky130_fd_sc_hd__decap_3
XFILLER_67_688 VGND VGND VPWR VPWR sky130_fd_sc_hd__decap_3
XFILLER_81_113 VGND VGND VPWR VPWR sky130_fd_sc_hd__fill_1
XFILLER_82_625 VGND VGND VPWR VPWR sky130_fd_sc_hd__fill_2
XFILLER_82_636 VGND VGND VPWR VPWR sky130_fd_sc_hd__decap_3
XFILLER_35_530 VGND VGND VPWR VPWR sky130_fd_sc_hd__decap_3
XFILLER_54_349 VGND VGND VPWR VPWR sky130_fd_sc_hd__decap_3
XFILLER_82_669 VGND VGND VPWR VPWR sky130_fd_sc_hd__decap_3
X_6922_ _6975_/CLK _6922_/D VGND VGND VPWR VPWR _6922_/Q sky130_fd_sc_hd__dfxtp_2
XFILLER_81_157 VGND VGND VPWR VPWR sky130_fd_sc_hd__decap_3
X_6853_ _6978_/CLK _6853_/D VGND VGND VPWR VPWR _6853_/Q sky130_fd_sc_hd__dfxtp_2
XFILLER_22_224 VGND VGND VPWR VPWR sky130_fd_sc_hd__fill_1
XFILLER_50_533 VGND VGND VPWR VPWR sky130_fd_sc_hd__decap_3
XFILLER_62_371 VGND VGND VPWR VPWR sky130_fd_sc_hd__fill_2
XFILLER_90_691 VGND VGND VPWR VPWR sky130_fd_sc_hd__fill_1
Xfanout17 _6536_/A VGND VGND VPWR VPWR _6347_/A sky130_fd_sc_hd__buf_2
Xfanout28 _6600_/A VGND VGND VPWR VPWR _6664_/A sky130_fd_sc_hd__clkdlybuf4s25_1
Xfanout39 fanout51/X VGND VGND VPWR VPWR fanout39/X sky130_fd_sc_hd__buf_1
X_6784_ _6975_/CLK _6784_/D VGND VGND VPWR VPWR _6784_/Q sky130_fd_sc_hd__dfxtp_2
X_3996_ _7344_/Q _4534_/A0 _3996_/S VGND VGND VPWR VPWR _7344_/D sky130_fd_sc_hd__mux2_2
XFILLER_13_38 VGND VGND VPWR VPWR sky130_fd_sc_hd__decap_3
X_5735_ _7373_/Q hold933/X _5737_/S VGND VGND VPWR VPWR _6717_/D sky130_fd_sc_hd__mux2_2
XFILLER_30_290 VGND VGND VPWR VPWR sky130_fd_sc_hd__fill_1
X_5666_ _5666_/A _5666_/B VGND VGND VPWR VPWR _5668_/B sky130_fd_sc_hd__or2_2
XTAP_TAPCELL_ROW_79_1202 VGND VPWR sky130_fd_sc_hd__tapvpwrvgnd_1
XFILLER_108_318 VGND VGND VPWR VPWR sky130_fd_sc_hd__fill_2
X_7405_ _7406_/CLK _7405_/D _6685_/Y VGND VGND VPWR VPWR _7405_/Q sky130_fd_sc_hd__dfrtp_2
X_4617_ _5114_/B _4617_/B _4617_/C VGND VGND VPWR VPWR _5099_/A sky130_fd_sc_hd__or3_4
XFILLER_116_340 VGND VGND VPWR VPWR sky130_fd_sc_hd__fill_2
X_5597_ hold959/X _5587_/B _5154_/Y VGND VGND VPWR VPWR _7029_/D sky130_fd_sc_hd__a21o_2
XFILLER_116_362 VGND VGND VPWR VPWR sky130_fd_sc_hd__fill_2
XFILLER_2_618 VGND VGND VPWR VPWR sky130_fd_sc_hd__decap_3
X_7336_ _7368_/CLK _7336_/D _6616_/Y VGND VGND VPWR VPWR _7336_/Q sky130_fd_sc_hd__dfrtp_2
X_4548_ _4548_/A _4567_/B VGND VGND VPWR VPWR _7306_/D sky130_fd_sc_hd__and2_2
XFILLER_1_128 VGND VGND VPWR VPWR sky130_fd_sc_hd__decap_3
XFILLER_89_246 VGND VGND VPWR VPWR sky130_fd_sc_hd__decap_3
X_7267_ _7267_/CLK _7267_/D _6547_/Y VGND VGND VPWR VPWR _7267_/Q sky130_fd_sc_hd__dfrtp_2
XFILLER_38_24 VGND VGND VPWR VPWR sky130_fd_sc_hd__decap_3
XFILLER_58_633 VGND VGND VPWR VPWR sky130_fd_sc_hd__decap_3
X_7198_ _7230_/CLK _7198_/D _6478_/Y VGND VGND VPWR VPWR _7198_/Q sky130_fd_sc_hd__dfrtp_2
XFILLER_38_46 VGND VGND VPWR VPWR sky130_fd_sc_hd__decap_3
XFILLER_57_121 VGND VGND VPWR VPWR sky130_fd_sc_hd__fill_2
XFILLER_58_666 VGND VGND VPWR VPWR sky130_fd_sc_hd__decap_3
XFILLER_85_452 VGND VGND VPWR VPWR sky130_fd_sc_hd__decap_3
XFILLER_97_290 VGND VGND VPWR VPWR sky130_fd_sc_hd__decap_3
Xhold1120 _7135_/Q VGND VGND VPWR VPWR _5396_/A0 sky130_fd_sc_hd__dlygate4sd3_1
Xhold1131 _7161_/Q VGND VGND VPWR VPWR _5340_/A0 sky130_fd_sc_hd__dlygate4sd3_1
Xhold1142 _7228_/Q VGND VGND VPWR VPWR _5200_/A sky130_fd_sc_hd__dlygate4sd3_1
XFILLER_45_305 VGND VGND VPWR VPWR sky130_fd_sc_hd__decap_3
XFILLER_73_614 VGND VGND VPWR VPWR sky130_fd_sc_hd__fill_2
XFILLER_85_485 VGND VGND VPWR VPWR sky130_fd_sc_hd__decap_3
Xhold1153 _7176_/Q VGND VGND VPWR VPWR _5308_/A0 sky130_fd_sc_hd__dlygate4sd3_1
Xhold1164 _7171_/Q VGND VGND VPWR VPWR _5319_/A0 sky130_fd_sc_hd__dlygate4sd3_1
Xhold1175 _7121_/Q VGND VGND VPWR VPWR _5425_/A0 sky130_fd_sc_hd__dlygate4sd3_1
XPHY_EDGE_ROW_79_Right_79 VGND VGND VPWR VPWR sky130_fd_sc_hd__decap_3
XFILLER_54_12 VGND VGND VPWR VPWR sky130_fd_sc_hd__decap_3
Xhold1186 _7141_/Q VGND VGND VPWR VPWR _5383_/A0 sky130_fd_sc_hd__dlygate4sd3_1
Xhold1197 _7256_/Q VGND VGND VPWR VPWR _5095_/A0 sky130_fd_sc_hd__dlygate4sd3_1
XFILLER_54_56 VGND VGND VPWR VPWR sky130_fd_sc_hd__decap_3
XFILLER_72_157 VGND VGND VPWR VPWR sky130_fd_sc_hd__fill_1
XFILLER_72_179 VGND VGND VPWR VPWR sky130_fd_sc_hd__decap_3
XFILLER_13_202 VGND VGND VPWR VPWR sky130_fd_sc_hd__decap_3
XFILLER_26_585 VGND VGND VPWR VPWR sky130_fd_sc_hd__decap_3
XFILLER_53_371 VGND VGND VPWR VPWR sky130_fd_sc_hd__decap_3
XFILLER_53_382 VGND VGND VPWR VPWR sky130_fd_sc_hd__decap_3
XFILLER_53_393 VGND VGND VPWR VPWR sky130_fd_sc_hd__decap_3
XFILLER_81_691 VGND VGND VPWR VPWR sky130_fd_sc_hd__fill_1
XFILLER_110_62 VGND VGND VPWR VPWR sky130_fd_sc_hd__decap_3
XFILLER_13_246 VGND VGND VPWR VPWR sky130_fd_sc_hd__decap_3
XFILLER_41_544 VGND VGND VPWR VPWR sky130_fd_sc_hd__decap_3
XFILLER_70_44 VGND VGND VPWR VPWR sky130_fd_sc_hd__fill_2
XFILLER_9_228 VGND VGND VPWR VPWR sky130_fd_sc_hd__decap_3
XFILLER_21_290 VGND VGND VPWR VPWR sky130_fd_sc_hd__decap_3
XFILLER_5_401 VGND VGND VPWR VPWR sky130_fd_sc_hd__decap_3
XPHY_EDGE_ROW_88_Right_88 VGND VGND VPWR VPWR sky130_fd_sc_hd__decap_3
XFILLER_107_351 VGND VGND VPWR VPWR sky130_fd_sc_hd__decap_3
XFILLER_79_31 VGND VGND VPWR VPWR sky130_fd_sc_hd__decap_3
XFILLER_79_75 VGND VGND VPWR VPWR sky130_fd_sc_hd__decap_3
XFILLER_1_662 VGND VGND VPWR VPWR sky130_fd_sc_hd__decap_3
XFILLER_68_419 VGND VGND VPWR VPWR sky130_fd_sc_hd__fill_1
XFILLER_95_205 VGND VGND VPWR VPWR sky130_fd_sc_hd__decap_3
XFILLER_0_172 VGND VGND VPWR VPWR sky130_fd_sc_hd__decap_3
XFILLER_1_673 VGND VGND VPWR VPWR sky130_fd_sc_hd__decap_3
XFILLER_49_611 VGND VGND VPWR VPWR sky130_fd_sc_hd__decap_3
XFILLER_95_41 VGND VGND VPWR VPWR sky130_fd_sc_hd__decap_3
XFILLER_48_132 VGND VGND VPWR VPWR sky130_fd_sc_hd__decap_3
XFILLER_49_644 VGND VGND VPWR VPWR sky130_fd_sc_hd__decap_3
XFILLER_76_441 VGND VGND VPWR VPWR sky130_fd_sc_hd__fill_1
XPHY_EDGE_ROW_97_Right_97 VGND VGND VPWR VPWR sky130_fd_sc_hd__decap_3
XFILLER_48_165 VGND VGND VPWR VPWR sky130_fd_sc_hd__decap_3
XFILLER_49_688 VGND VGND VPWR VPWR sky130_fd_sc_hd__decap_3
XFILLER_63_102 VGND VGND VPWR VPWR sky130_fd_sc_hd__decap_3
XFILLER_64_625 VGND VGND VPWR VPWR sky130_fd_sc_hd__decap_3
XFILLER_95_96 VGND VGND VPWR VPWR sky130_fd_sc_hd__decap_3
XTAP_TAPCELL_ROW_47_812 VGND VPWR sky130_fd_sc_hd__tapvpwrvgnd_1
XFILLER_63_124 VGND VGND VPWR VPWR sky130_fd_sc_hd__decap_3
XFILLER_64_669 VGND VGND VPWR VPWR sky130_fd_sc_hd__decap_3
XFILLER_91_444 VGND VGND VPWR VPWR sky130_fd_sc_hd__decap_3
XFILLER_51_308 VGND VGND VPWR VPWR sky130_fd_sc_hd__decap_3
XFILLER_63_179 VGND VGND VPWR VPWR sky130_fd_sc_hd__fill_2
XFILLER_44_360 VGND VGND VPWR VPWR sky130_fd_sc_hd__decap_3
XTAP_TAPCELL_ROW_63_1003 VGND VPWR sky130_fd_sc_hd__tapvpwrvgnd_1
XTAP_TAPCELL_ROW_27_580 VGND VPWR sky130_fd_sc_hd__tapvpwrvgnd_1
X_3850_ _6810_/Q _3853_/B1 _3665_/X _6820_/Q VGND VGND VPWR VPWR _3850_/X sky130_fd_sc_hd__a22o_2
XPHY_EDGE_ROW_4_Left_121 VGND VGND VPWR VPWR sky130_fd_sc_hd__decap_3
X_3781_ _6949_/Q _3853_/B1 _3665_/X _6961_/Q _3780_/X VGND VGND VPWR VPWR _3781_/X
+ sky130_fd_sc_hd__a221o_2
XFILLER_8_250 VGND VGND VPWR VPWR sky130_fd_sc_hd__fill_2
XFILLER_8_272 VGND VGND VPWR VPWR sky130_fd_sc_hd__decap_3
XFILLER_8_283 VGND VGND VPWR VPWR sky130_fd_sc_hd__decap_3
Xoutput536 _7001_/Q VGND VGND VPWR VPWR pc_out[24] sky130_fd_sc_hd__clkdlybuf4s25_1
Xoutput525 _6991_/Q VGND VGND VPWR VPWR pc_out[14] sky130_fd_sc_hd__clkdlybuf4s25_1
Xoutput514 _5640_/Y VGND VGND VPWR VPWR instruction_out[4] sky130_fd_sc_hd__clkdlybuf4s25_1
Xoutput503 _3417_/C VGND VGND VPWR VPWR instruction_out[21] sky130_fd_sc_hd__clkdlybuf4s25_1
X_4402_ _7082_/Q _4432_/A2 _4142_/A _4401_/X VGND VGND VPWR VPWR _4403_/A sky130_fd_sc_hd__o211a_2
XFILLER_99_511 VGND VGND VPWR VPWR sky130_fd_sc_hd__fill_2
XFILLER_5_72 VGND VGND VPWR VPWR sky130_fd_sc_hd__decap_3
X_7121_ _7356_/CLK _7121_/D _6401_/Y VGND VGND VPWR VPWR _7121_/Q sky130_fd_sc_hd__dfrtp_2
Xoutput547 _5129_/A VGND VGND VPWR VPWR pc_out[5] sky130_fd_sc_hd__clkdlybuf4s25_1
X_4333_ _7127_/Q _4351_/B1 _4332_/X VGND VGND VPWR VPWR _4336_/A sky130_fd_sc_hd__a21o_2
XTAP_TAPCELL_ROW_74_1143 VGND VPWR sky130_fd_sc_hd__tapvpwrvgnd_1
XFILLER_99_555 VGND VGND VPWR VPWR sky130_fd_sc_hd__decap_3
XFILLER_101_505 VGND VGND VPWR VPWR sky130_fd_sc_hd__decap_3
XFILLER_86_205 VGND VGND VPWR VPWR sky130_fd_sc_hd__decap_3
X_7052_ _7341_/CLK _7052_/D _6332_/Y VGND VGND VPWR VPWR _7052_/Q sky130_fd_sc_hd__dfrtp_2
X_4264_ _4264_/A _4264_/B VGND VGND VPWR VPWR _4376_/B sky130_fd_sc_hd__nor2_2
XFILLER_99_566 VGND VGND VPWR VPWR sky130_fd_sc_hd__decap_3
XFILLER_101_538 VGND VGND VPWR VPWR sky130_fd_sc_hd__decap_3
XFILLER_113_376 VGND VGND VPWR VPWR sky130_fd_sc_hd__decap_3
XFILLER_115_29 VGND VGND VPWR VPWR sky130_fd_sc_hd__decap_3
XFILLER_99_599 VGND VGND VPWR VPWR sky130_fd_sc_hd__decap_3
XFILLER_39_143 VGND VGND VPWR VPWR sky130_fd_sc_hd__decap_3
XFILLER_67_441 VGND VGND VPWR VPWR sky130_fd_sc_hd__decap_3
XFILLER_79_290 VGND VGND VPWR VPWR sky130_fd_sc_hd__decap_3
X_4195_ _7135_/Q _4195_/A2 _4267_/B1 _7167_/Q VGND VGND VPWR VPWR _4195_/X sky130_fd_sc_hd__a22o_2
XFILLER_27_316 VGND VGND VPWR VPWR sky130_fd_sc_hd__decap_3
XFILLER_39_165 VGND VGND VPWR VPWR sky130_fd_sc_hd__decap_3
XFILLER_55_603 VGND VGND VPWR VPWR sky130_fd_sc_hd__decap_3
XFILLER_94_271 VGND VGND VPWR VPWR sky130_fd_sc_hd__decap_3
XFILLER_39_187 VGND VGND VPWR VPWR sky130_fd_sc_hd__decap_3
XFILLER_55_647 VGND VGND VPWR VPWR sky130_fd_sc_hd__decap_3
XFILLER_82_477 VGND VGND VPWR VPWR sky130_fd_sc_hd__decap_3
X_6905_ _6929_/CLK _6905_/D VGND VGND VPWR VPWR _6905_/Q sky130_fd_sc_hd__dfxtp_2
XFILLER_23_500 VGND VGND VPWR VPWR sky130_fd_sc_hd__decap_3
XFILLER_35_371 VGND VGND VPWR VPWR sky130_fd_sc_hd__decap_3
XFILLER_35_382 VGND VGND VPWR VPWR sky130_fd_sc_hd__fill_1
XTAP_TAPCELL_ROW_85_1272 VGND VPWR sky130_fd_sc_hd__tapvpwrvgnd_1
XFILLER_24_26 VGND VGND VPWR VPWR sky130_fd_sc_hd__fill_2
XFILLER_35_393 VGND VGND VPWR VPWR sky130_fd_sc_hd__decap_3
XFILLER_62_190 VGND VGND VPWR VPWR sky130_fd_sc_hd__decap_3
X_6836_ _6964_/CLK _6836_/D VGND VGND VPWR VPWR _6836_/Q sky130_fd_sc_hd__dfxtp_2
XPHY_EDGE_ROW_59_Left_176 VGND VGND VPWR VPWR sky130_fd_sc_hd__decap_3
XFILLER_10_205 VGND VGND VPWR VPWR sky130_fd_sc_hd__decap_3
XFILLER_50_374 VGND VGND VPWR VPWR sky130_fd_sc_hd__decap_3
X_6767_ _6975_/CLK _6767_/D VGND VGND VPWR VPWR _6767_/Q sky130_fd_sc_hd__dfxtp_2
XFILLER_10_249 VGND VGND VPWR VPWR sky130_fd_sc_hd__decap_3
X_3979_ _7351_/Q _4520_/A0 _3979_/S VGND VGND VPWR VPWR _7351_/D sky130_fd_sc_hd__mux2_2
XFILLER_108_104 VGND VGND VPWR VPWR sky130_fd_sc_hd__decap_3
XFILLER_109_638 VGND VGND VPWR VPWR sky130_fd_sc_hd__decap_3
XFILLER_40_25 VGND VGND VPWR VPWR sky130_fd_sc_hd__decap_3
X_6698_ _6931_/CLK _6698_/D VGND VGND VPWR VPWR _6698_/Q sky130_fd_sc_hd__dfxtp_2
XFILLER_108_137 VGND VGND VPWR VPWR sky130_fd_sc_hd__decap_3
XFILLER_40_69 VGND VGND VPWR VPWR sky130_fd_sc_hd__decap_3
X_5649_ _5649_/A VGND VGND VPWR VPWR _5649_/X sky130_fd_sc_hd__buf_1
XFILLER_2_404 VGND VGND VPWR VPWR sky130_fd_sc_hd__decap_3
XFILLER_116_181 VGND VGND VPWR VPWR sky130_fd_sc_hd__fill_1
XFILLER_2_448 VGND VGND VPWR VPWR sky130_fd_sc_hd__decap_3
XFILLER_49_12 VGND VGND VPWR VPWR sky130_fd_sc_hd__decap_3
XFILLER_6_6 VGND VGND VPWR VPWR sky130_fd_sc_hd__decap_3
X_7319_ clkload5/A _7319_/D _6599_/Y VGND VGND VPWR VPWR _7319_/Q sky130_fd_sc_hd__dfrtp_2
XPHY_EDGE_ROW_68_Left_185 VGND VGND VPWR VPWR sky130_fd_sc_hd__decap_3
XFILLER_104_365 VGND VGND VPWR VPWR sky130_fd_sc_hd__decap_3
XFILLER_105_51 VGND VGND VPWR VPWR sky130_fd_sc_hd__decap_3
XFILLER_105_73 VGND VGND VPWR VPWR sky130_fd_sc_hd__decap_3
XFILLER_105_84 VGND VGND VPWR VPWR sky130_fd_sc_hd__decap_3
XFILLER_18_305 VGND VGND VPWR VPWR sky130_fd_sc_hd__decap_3
XFILLER_46_603 VGND VGND VPWR VPWR sky130_fd_sc_hd__decap_3
XFILLER_58_474 VGND VGND VPWR VPWR sky130_fd_sc_hd__fill_2
XFILLER_58_485 VGND VGND VPWR VPWR sky130_fd_sc_hd__decap_3
XFILLER_18_327 VGND VGND VPWR VPWR sky130_fd_sc_hd__decap_3
XFILLER_45_113 VGND VGND VPWR VPWR sky130_fd_sc_hd__fill_2
XFILLER_46_636 VGND VGND VPWR VPWR sky130_fd_sc_hd__decap_3
XFILLER_58_496 VGND VGND VPWR VPWR sky130_fd_sc_hd__decap_3
XFILLER_65_44 VGND VGND VPWR VPWR sky130_fd_sc_hd__decap_3
XFILLER_73_433 VGND VGND VPWR VPWR sky130_fd_sc_hd__decap_3
XFILLER_46_669 VGND VGND VPWR VPWR sky130_fd_sc_hd__decap_3
XFILLER_61_617 VGND VGND VPWR VPWR sky130_fd_sc_hd__decap_3
XFILLER_65_77 VGND VGND VPWR VPWR sky130_fd_sc_hd__decap_3
XFILLER_73_455 VGND VGND VPWR VPWR sky130_fd_sc_hd__decap_3
XFILLER_14_511 VGND VGND VPWR VPWR sky130_fd_sc_hd__fill_2
XFILLER_26_371 VGND VGND VPWR VPWR sky130_fd_sc_hd__decap_3
XPHY_EDGE_ROW_77_Left_194 VGND VGND VPWR VPWR sky130_fd_sc_hd__decap_3
XFILLER_14_533 VGND VGND VPWR VPWR sky130_fd_sc_hd__decap_3
XFILLER_81_21 VGND VGND VPWR VPWR sky130_fd_sc_hd__decap_3
XFILLER_41_352 VGND VGND VPWR VPWR sky130_fd_sc_hd__decap_3
XFILLER_81_76 VGND VGND VPWR VPWR sky130_fd_sc_hd__decap_3
XFILLER_81_87 VGND VGND VPWR VPWR sky130_fd_sc_hd__decap_3
XTAP_TAPCELL_ROW_52_881 VGND VPWR sky130_fd_sc_hd__tapvpwrvgnd_1
XTAP_TAPCELL_ROW_52_870 VGND VPWR sky130_fd_sc_hd__tapvpwrvgnd_1
XFILLER_5_231 VGND VGND VPWR VPWR sky130_fd_sc_hd__fill_1
XFILLER_108_660 VGND VGND VPWR VPWR sky130_fd_sc_hd__decap_3
XFILLER_107_181 VGND VGND VPWR VPWR sky130_fd_sc_hd__decap_3
XFILLER_114_118 VGND VGND VPWR VPWR sky130_fd_sc_hd__decap_3
XFILLER_30_91 VGND VGND VPWR VPWR sky130_fd_sc_hd__decap_3
XFILLER_5_275 VGND VGND VPWR VPWR sky130_fd_sc_hd__decap_3
XFILLER_1_470 VGND VGND VPWR VPWR sky130_fd_sc_hd__fill_2
XFILLER_39_6 VGND VGND VPWR VPWR sky130_fd_sc_hd__decap_3
XFILLER_68_216 VGND VGND VPWR VPWR sky130_fd_sc_hd__fill_2
XFILLER_96_525 VGND VGND VPWR VPWR sky130_fd_sc_hd__decap_3
XFILLER_68_249 VGND VGND VPWR VPWR sky130_fd_sc_hd__decap_3
XFILLER_96_558 VGND VGND VPWR VPWR sky130_fd_sc_hd__decap_3
XFILLER_110_368 VGND VGND VPWR VPWR sky130_fd_sc_hd__fill_1
XFILLER_83_219 VGND VGND VPWR VPWR sky130_fd_sc_hd__decap_3
XFILLER_36_102 VGND VGND VPWR VPWR sky130_fd_sc_hd__decap_3
XFILLER_37_647 VGND VGND VPWR VPWR sky130_fd_sc_hd__fill_2
XFILLER_64_433 VGND VGND VPWR VPWR sky130_fd_sc_hd__decap_3
XFILLER_64_444 VGND VGND VPWR VPWR sky130_fd_sc_hd__decap_3
XTAP_TAPCELL_ROW_108_1548 VGND VPWR sky130_fd_sc_hd__tapvpwrvgnd_1
XFILLER_91_252 VGND VGND VPWR VPWR sky130_fd_sc_hd__decap_3
XFILLER_45_691 VGND VGND VPWR VPWR sky130_fd_sc_hd__fill_1
XFILLER_51_116 VGND VGND VPWR VPWR sky130_fd_sc_hd__decap_3
XFILLER_52_628 VGND VGND VPWR VPWR sky130_fd_sc_hd__decap_3
X_4951_ _4949_/Y _4950_/Y _4918_/B VGND VGND VPWR VPWR _4951_/Y sky130_fd_sc_hd__a21oi_2
XFILLER_17_393 VGND VGND VPWR VPWR sky130_fd_sc_hd__decap_3
XFILLER_51_138 VGND VGND VPWR VPWR sky130_fd_sc_hd__decap_3
X_4882_ _4882_/A _4882_/B VGND VGND VPWR VPWR _6998_/D sky130_fd_sc_hd__and2_2
X_3902_ _6918_/Q _3902_/A2 _3925_/B1 _6870_/Q VGND VGND VPWR VPWR _3902_/X sky130_fd_sc_hd__a22o_2
XFILLER_60_672 VGND VGND VPWR VPWR sky130_fd_sc_hd__decap_3
X_6621_ _6682_/A VGND VGND VPWR VPWR _6621_/Y sky130_fd_sc_hd__inv_2
X_3833_ _3833_/A0 _3832_/X _3833_/S VGND VGND VPWR VPWR _7388_/D sky130_fd_sc_hd__mux2_2
X_6552_ _6584_/A VGND VGND VPWR VPWR _6552_/Y sky130_fd_sc_hd__inv_2
X_3764_ _6706_/Q _6796_/Q _6884_/Q _6932_/Q _3991_/B _3665_/B VGND VGND VPWR VPWR
+ _3764_/X sky130_fd_sc_hd__mux4_2
X_6483_ _6483_/A VGND VGND VPWR VPWR _6483_/Y sky130_fd_sc_hd__inv_2
X_3695_ _6714_/Q _3767_/A2 _3826_/B1 _6892_/Q VGND VGND VPWR VPWR _3695_/X sky130_fd_sc_hd__a22o_2
XFILLER_105_107 VGND VGND VPWR VPWR sky130_fd_sc_hd__decap_3
XFILLER_113_140 VGND VGND VPWR VPWR sky130_fd_sc_hd__decap_3
XFILLER_114_663 VGND VGND VPWR VPWR sky130_fd_sc_hd__decap_3
X_7104_ _7264_/CLK _7104_/D _6384_/Y VGND VGND VPWR VPWR _7104_/Q sky130_fd_sc_hd__dfrtp_2
X_5365_ _5365_/A0 _4716_/X _5383_/S VGND VGND VPWR VPWR _7150_/D sky130_fd_sc_hd__mux2_4
XFILLER_99_363 VGND VGND VPWR VPWR sky130_fd_sc_hd__decap_3
XFILLER_101_302 VGND VGND VPWR VPWR sky130_fd_sc_hd__decap_3
XFILLER_87_514 VGND VGND VPWR VPWR sky130_fd_sc_hd__decap_3
X_5296_ _7182_/Q _4716_/X _5323_/S VGND VGND VPWR VPWR _7182_/D sky130_fd_sc_hd__mux2_4
X_4316_ _7226_/Q _4349_/B1 _4348_/B1 _7130_/Q VGND VGND VPWR VPWR _4316_/X sky130_fd_sc_hd__a22o_2
XFILLER_99_396 VGND VGND VPWR VPWR sky130_fd_sc_hd__decap_3
XFILLER_101_335 VGND VGND VPWR VPWR sky130_fd_sc_hd__fill_1
XFILLER_101_346 VGND VGND VPWR VPWR sky130_fd_sc_hd__decap_3
XFILLER_101_357 VGND VGND VPWR VPWR sky130_fd_sc_hd__decap_3
XFILLER_113_184 VGND VGND VPWR VPWR sky130_fd_sc_hd__decap_3
XFILLER_19_26 VGND VGND VPWR VPWR sky130_fd_sc_hd__decap_3
XFILLER_87_558 VGND VGND VPWR VPWR sky130_fd_sc_hd__fill_2
X_7035_ _7384_/CLK _7035_/D _6315_/Y VGND VGND VPWR VPWR _7035_/Q sky130_fd_sc_hd__dfrtp_2
X_4247_ _7261_/Q _4408_/A2 _3962_/S _7325_/Q _4246_/X VGND VGND VPWR VPWR _4248_/C
+ sky130_fd_sc_hd__a221o_2
XFILLER_28_603 VGND VGND VPWR VPWR sky130_fd_sc_hd__fill_2
XFILLER_28_625 VGND VGND VPWR VPWR sky130_fd_sc_hd__fill_2
XFILLER_55_400 VGND VGND VPWR VPWR sky130_fd_sc_hd__fill_1
X_4178_ _7264_/Q _4408_/A2 _4177_/X VGND VGND VPWR VPWR _4178_/Y sky130_fd_sc_hd__a21oi_2
XTAP_TAPCELL_ROW_87_1301 VGND VPWR sky130_fd_sc_hd__tapvpwrvgnd_1
XFILLER_27_113 VGND VGND VPWR VPWR sky130_fd_sc_hd__decap_3
XFILLER_15_308 VGND VGND VPWR VPWR sky130_fd_sc_hd__decap_3
XFILLER_43_617 VGND VGND VPWR VPWR sky130_fd_sc_hd__decap_3
XFILLER_55_466 VGND VGND VPWR VPWR sky130_fd_sc_hd__decap_3
XTAP_TAPCELL_ROW_2_278 VGND VPWR sky130_fd_sc_hd__tapvpwrvgnd_1
XFILLER_42_116 VGND VGND VPWR VPWR sky130_fd_sc_hd__decap_3
XFILLER_82_296 VGND VGND VPWR VPWR sky130_fd_sc_hd__decap_3
XFILLER_35_190 VGND VGND VPWR VPWR sky130_fd_sc_hd__decap_3
XFILLER_35_69 VGND VGND VPWR VPWR sky130_fd_sc_hd__decap_3
XFILLER_51_650 VGND VGND VPWR VPWR sky130_fd_sc_hd__decap_3
X_6819_ _6965_/CLK _6819_/D VGND VGND VPWR VPWR _6819_/Q sky130_fd_sc_hd__dfxtp_2
XFILLER_23_396 VGND VGND VPWR VPWR sky130_fd_sc_hd__decap_3
XFILLER_50_171 VGND VGND VPWR VPWR sky130_fd_sc_hd__decap_3
XFILLER_51_24 VGND VGND VPWR VPWR sky130_fd_sc_hd__decap_3
XFILLER_109_402 VGND VGND VPWR VPWR sky130_fd_sc_hd__decap_3
XFILLER_51_57 VGND VGND VPWR VPWR sky130_fd_sc_hd__fill_2
XFILLER_51_79 VGND VGND VPWR VPWR sky130_fd_sc_hd__decap_3
XTAP_TAPCELL_ROW_98_1430 VGND VPWR sky130_fd_sc_hd__tapvpwrvgnd_1
XFILLER_105_652 VGND VGND VPWR VPWR sky130_fd_sc_hd__decap_3
XFILLER_2_256 VGND VGND VPWR VPWR sky130_fd_sc_hd__decap_3
XFILLER_4_3 VGND VGND VPWR VPWR sky130_fd_sc_hd__decap_3
XFILLER_105_685 VGND VGND VPWR VPWR sky130_fd_sc_hd__decap_3
XFILLER_116_50 VGND VGND VPWR VPWR sky130_fd_sc_hd__decap_3
XFILLER_2_289 VGND VGND VPWR VPWR sky130_fd_sc_hd__decap_3
XFILLER_78_525 VGND VGND VPWR VPWR sky130_fd_sc_hd__decap_3
XFILLER_116_83 VGND VGND VPWR VPWR sky130_fd_sc_hd__fill_1
XFILLER_116_94 VGND VGND VPWR VPWR sky130_fd_sc_hd__decap_3
XFILLER_46_400 VGND VGND VPWR VPWR sky130_fd_sc_hd__decap_3
XFILLER_65_208 VGND VGND VPWR VPWR sky130_fd_sc_hd__decap_3
XFILLER_76_54 VGND VGND VPWR VPWR sky130_fd_sc_hd__fill_2
XFILLER_76_76 VGND VGND VPWR VPWR sky130_fd_sc_hd__decap_3
XFILLER_18_124 VGND VGND VPWR VPWR sky130_fd_sc_hd__decap_3
XFILLER_19_625 VGND VGND VPWR VPWR sky130_fd_sc_hd__fill_2
XFILLER_76_98 VGND VGND VPWR VPWR sky130_fd_sc_hd__fill_1
XFILLER_19_669 VGND VGND VPWR VPWR sky130_fd_sc_hd__decap_3
XFILLER_34_617 VGND VGND VPWR VPWR sky130_fd_sc_hd__decap_3
XFILLER_46_455 VGND VGND VPWR VPWR sky130_fd_sc_hd__decap_3
XFILLER_73_252 VGND VGND VPWR VPWR sky130_fd_sc_hd__decap_3
Xplace75 _5657_/B VGND VGND VPWR VPWR place75/X sky130_fd_sc_hd__buf_2
XTAP_TAPCELL_ROW_57_940 VGND VPWR sky130_fd_sc_hd__tapvpwrvgnd_1
XPHY_EDGE_ROW_85_Left_202 VGND VGND VPWR VPWR sky130_fd_sc_hd__decap_3
XFILLER_33_105 VGND VGND VPWR VPWR sky130_fd_sc_hd__decap_3
XFILLER_33_116 VGND VGND VPWR VPWR sky130_fd_sc_hd__decap_3
XFILLER_61_414 VGND VGND VPWR VPWR sky130_fd_sc_hd__decap_3
XFILLER_33_138 VGND VGND VPWR VPWR sky130_fd_sc_hd__decap_3
XFILLER_61_447 VGND VGND VPWR VPWR sky130_fd_sc_hd__fill_1
XFILLER_92_97 VGND VGND VPWR VPWR sky130_fd_sc_hd__decap_3
XFILLER_14_363 VGND VGND VPWR VPWR sky130_fd_sc_hd__fill_1
XFILLER_42_672 VGND VGND VPWR VPWR sky130_fd_sc_hd__decap_3
XTAP_TAPCELL_ROW_103_1489 VGND VPWR sky130_fd_sc_hd__tapvpwrvgnd_1
XPHY_EDGE_ROW_94_Left_211 VGND VGND VPWR VPWR sky130_fd_sc_hd__decap_3
X_3480_ _7088_/Q _4321_/A2 _3407_/X _7120_/Q VGND VGND VPWR VPWR _3482_/B sky130_fd_sc_hd__a22o_2
XFILLER_115_449 VGND VGND VPWR VPWR sky130_fd_sc_hd__decap_3
XTAP_TAPCELL_ROW_71_1102 VGND VPWR sky130_fd_sc_hd__tapvpwrvgnd_1
XFILLER_111_600 VGND VGND VPWR VPWR sky130_fd_sc_hd__decap_3
XFILLER_37_3 VGND VGND VPWR VPWR sky130_fd_sc_hd__decap_3
X_5150_ _3501_/X _3618_/X _5145_/X _5149_/Y VGND VGND VPWR VPWR _5659_/B sky130_fd_sc_hd__a31o_2
XFILLER_111_644 VGND VGND VPWR VPWR sky130_fd_sc_hd__decap_3
XFILLER_96_344 VGND VGND VPWR VPWR sky130_fd_sc_hd__decap_3
X_4101_ _7141_/Q _4428_/B1 _4100_/X VGND VGND VPWR VPWR _4141_/A sky130_fd_sc_hd__a21oi_2
XFILLER_110_165 VGND VGND VPWR VPWR sky130_fd_sc_hd__decap_3
XFILLER_111_688 VGND VGND VPWR VPWR sky130_fd_sc_hd__decap_3
XFILLER_2_62 VGND VGND VPWR VPWR sky130_fd_sc_hd__decap_3
XFILLER_84_517 VGND VGND VPWR VPWR sky130_fd_sc_hd__fill_2
XFILLER_96_377 VGND VGND VPWR VPWR sky130_fd_sc_hd__fill_2
X_4032_ _7246_/Q _4433_/B _3947_/S _7214_/Q VGND VGND VPWR VPWR _4032_/X sky130_fd_sc_hd__a22o_2
XFILLER_110_187 VGND VGND VPWR VPWR sky130_fd_sc_hd__fill_1
XFILLER_37_455 VGND VGND VPWR VPWR sky130_fd_sc_hd__decap_3
XFILLER_64_241 VGND VGND VPWR VPWR sky130_fd_sc_hd__decap_3
XFILLER_92_561 VGND VGND VPWR VPWR sky130_fd_sc_hd__decap_3
XFILLER_24_116 VGND VGND VPWR VPWR sky130_fd_sc_hd__decap_3
XFILLER_25_617 VGND VGND VPWR VPWR sky130_fd_sc_hd__decap_3
XFILLER_52_414 VGND VGND VPWR VPWR sky130_fd_sc_hd__decap_3
XFILLER_64_274 VGND VGND VPWR VPWR sky130_fd_sc_hd__fill_1
XTAP_TAPCELL_ROW_69_1075 VGND VPWR sky130_fd_sc_hd__tapvpwrvgnd_1
XFILLER_17_190 VGND VGND VPWR VPWR sky130_fd_sc_hd__decap_3
XFILLER_18_691 VGND VGND VPWR VPWR sky130_fd_sc_hd__fill_1
XFILLER_40_609 VGND VGND VPWR VPWR sky130_fd_sc_hd__fill_1
XFILLER_52_436 VGND VGND VPWR VPWR sky130_fd_sc_hd__decap_3
XTAP_TAPCELL_ROW_82_1231 VGND VPWR sky130_fd_sc_hd__tapvpwrvgnd_1
XTAP_TAPCELL_ROW_35_667 VGND VPWR sky130_fd_sc_hd__tapvpwrvgnd_1
XFILLER_32_182 VGND VGND VPWR VPWR sky130_fd_sc_hd__decap_3
X_4865_ _4865_/A0 _4864_/X _4865_/S VGND VGND VPWR VPWR _7270_/D sky130_fd_sc_hd__mux2_2
X_6604_ _6604_/A VGND VGND VPWR VPWR _6604_/Y sky130_fd_sc_hd__inv_2
X_4796_ _4795_/A _4779_/X _4447_/B _4780_/Y _4814_/A VGND VGND VPWR VPWR _4796_/Y
+ sky130_fd_sc_hd__a311oi_2
X_3816_ _6792_/Q _3862_/B1 _3925_/B1 _6880_/Q _3815_/X VGND VGND VPWR VPWR _3816_/X
+ sky130_fd_sc_hd__a221o_2
XFILLER_20_399 VGND VGND VPWR VPWR sky130_fd_sc_hd__decap_3
X_6535_ _6535_/A VGND VGND VPWR VPWR _6535_/Y sky130_fd_sc_hd__inv_2
X_3747_ _3741_/X _3743_/X _3745_/X _3746_/X VGND VGND VPWR VPWR _3747_/X sky130_fd_sc_hd__a22o_2
XFILLER_108_9 VGND VGND VPWR VPWR sky130_fd_sc_hd__decap_3
X_6466_ _6634_/A VGND VGND VPWR VPWR _6466_/Y sky130_fd_sc_hd__inv_2
X_6397_ _6558_/A VGND VGND VPWR VPWR _6397_/Y sky130_fd_sc_hd__inv_2
X_5417_ _5417_/A0 _5125_/Y _5417_/S VGND VGND VPWR VPWR _7125_/D sky130_fd_sc_hd__mux2_2
XFILLER_102_622 VGND VGND VPWR VPWR sky130_fd_sc_hd__decap_3
X_5348_ _7157_/Q _5125_/Y _5350_/S VGND VGND VPWR VPWR _7157_/D sky130_fd_sc_hd__mux2_2
XTAP_TAPCELL_ROW_93_1371 VGND VPWR sky130_fd_sc_hd__tapvpwrvgnd_1
XTAP_TAPCELL_ROW_7_337 VGND VPWR sky130_fd_sc_hd__tapvpwrvgnd_1
XFILLER_101_110 VGND VGND VPWR VPWR sky130_fd_sc_hd__fill_2
XFILLER_101_143 VGND VGND VPWR VPWR sky130_fd_sc_hd__decap_3
XFILLER_102_666 VGND VGND VPWR VPWR sky130_fd_sc_hd__decap_3
XFILLER_75_517 VGND VGND VPWR VPWR sky130_fd_sc_hd__decap_3
X_7018_ _7267_/CLK _7018_/D _6298_/Y VGND VGND VPWR VPWR _7018_/Q sky130_fd_sc_hd__dfrtp_2
XFILLER_101_187 VGND VGND VPWR VPWR sky130_fd_sc_hd__decap_3
XFILLER_46_24 VGND VGND VPWR VPWR sky130_fd_sc_hd__decap_3
XFILLER_28_455 VGND VGND VPWR VPWR sky130_fd_sc_hd__fill_2
XFILLER_28_466 VGND VGND VPWR VPWR sky130_fd_sc_hd__fill_1
XFILLER_46_46 VGND VGND VPWR VPWR sky130_fd_sc_hd__decap_3
XFILLER_46_68 VGND VGND VPWR VPWR sky130_fd_sc_hd__fill_1
XFILLER_28_477 VGND VGND VPWR VPWR sky130_fd_sc_hd__fill_1
XFILLER_43_403 VGND VGND VPWR VPWR sky130_fd_sc_hd__fill_1
XFILLER_55_263 VGND VGND VPWR VPWR sky130_fd_sc_hd__decap_3
XFILLER_70_200 VGND VGND VPWR VPWR sky130_fd_sc_hd__decap_3
XFILLER_43_458 VGND VGND VPWR VPWR sky130_fd_sc_hd__decap_3
XFILLER_55_296 VGND VGND VPWR VPWR sky130_fd_sc_hd__decap_3
XFILLER_70_222 VGND VGND VPWR VPWR sky130_fd_sc_hd__fill_2
XFILLER_70_233 VGND VGND VPWR VPWR sky130_fd_sc_hd__fill_2
XFILLER_102_85 VGND VGND VPWR VPWR sky130_fd_sc_hd__decap_3
XFILLER_62_23 VGND VGND VPWR VPWR sky130_fd_sc_hd__decap_3
XFILLER_70_277 VGND VGND VPWR VPWR sky130_fd_sc_hd__decap_3
XFILLER_11_311 VGND VGND VPWR VPWR sky130_fd_sc_hd__decap_3
XFILLER_23_160 VGND VGND VPWR VPWR sky130_fd_sc_hd__decap_3
XFILLER_7_18 VGND VGND VPWR VPWR sky130_fd_sc_hd__decap_3
XFILLER_7_304 VGND VGND VPWR VPWR sky130_fd_sc_hd__decap_3
XFILLER_11_399 VGND VGND VPWR VPWR sky130_fd_sc_hd__decap_3
XFILLER_7_337 VGND VGND VPWR VPWR sky130_fd_sc_hd__fill_2
XFILLER_7_359 VGND VGND VPWR VPWR sky130_fd_sc_hd__decap_3
XFILLER_11_60 VGND VGND VPWR VPWR sky130_fd_sc_hd__decap_3
XFILLER_11_82 VGND VGND VPWR VPWR sky130_fd_sc_hd__decap_3
XFILLER_87_42 VGND VGND VPWR VPWR sky130_fd_sc_hd__decap_3
XFILLER_97_119 VGND VGND VPWR VPWR sky130_fd_sc_hd__fill_2
XFILLER_78_333 VGND VGND VPWR VPWR sky130_fd_sc_hd__decap_3
XFILLER_23_9 VGND VGND VPWR VPWR sky130_fd_sc_hd__decap_3
XFILLER_78_355 VGND VGND VPWR VPWR sky130_fd_sc_hd__decap_3
XFILLER_19_411 VGND VGND VPWR VPWR sky130_fd_sc_hd__decap_3
XFILLER_19_433 VGND VGND VPWR VPWR sky130_fd_sc_hd__decap_3
XFILLER_93_358 VGND VGND VPWR VPWR sky130_fd_sc_hd__decap_3
XFILLER_19_488 VGND VGND VPWR VPWR sky130_fd_sc_hd__decap_3
XFILLER_46_263 VGND VGND VPWR VPWR sky130_fd_sc_hd__decap_3
XFILLER_61_211 VGND VGND VPWR VPWR sky130_fd_sc_hd__decap_3
XFILLER_74_561 VGND VGND VPWR VPWR sky130_fd_sc_hd__fill_2
XFILLER_74_572 VGND VGND VPWR VPWR sky130_fd_sc_hd__fill_1
XTAP_TAPCELL_ROW_105_1507 VGND VPWR sky130_fd_sc_hd__tapvpwrvgnd_1
XFILLER_34_458 VGND VGND VPWR VPWR sky130_fd_sc_hd__decap_3
XFILLER_61_255 VGND VGND VPWR VPWR sky130_fd_sc_hd__decap_3
XFILLER_14_182 VGND VGND VPWR VPWR sky130_fd_sc_hd__decap_3
XFILLER_21_119 VGND VGND VPWR VPWR sky130_fd_sc_hd__decap_3
XFILLER_30_620 VGND VGND VPWR VPWR sky130_fd_sc_hd__fill_2
XFILLER_61_299 VGND VGND VPWR VPWR sky130_fd_sc_hd__decap_3
XTAP_TAPCELL_ROW_32_637 VGND VPWR sky130_fd_sc_hd__tapvpwrvgnd_1
XFILLER_30_642 VGND VGND VPWR VPWR sky130_fd_sc_hd__fill_2
X_4650_ _4440_/A _4650_/B VGND VGND VPWR VPWR _4810_/B sky130_fd_sc_hd__and2b_2
XTAP_TAPCELL_ROW_60_968 VGND VPWR sky130_fd_sc_hd__tapvpwrvgnd_1
X_3601_ _3427_/B _3600_/Y _3599_/A VGND VGND VPWR VPWR _4613_/B sky130_fd_sc_hd__a21oi_2
X_6320_ _6644_/A VGND VGND VPWR VPWR _6320_/Y sky130_fd_sc_hd__inv_2
X_4581_ _7290_/Q _4595_/B VGND VGND VPWR VPWR _7290_/D sky130_fd_sc_hd__and2_2
XTAP_TAPCELL_ROW_12_394 VGND VPWR sky130_fd_sc_hd__tapvpwrvgnd_1
XFILLER_115_202 VGND VGND VPWR VPWR sky130_fd_sc_hd__decap_3
Xhold805 _6907_/Q VGND VGND VPWR VPWR _6907_/D sky130_fd_sc_hd__dlygate4sd3_1
Xhold816 _6826_/Q VGND VGND VPWR VPWR _6826_/D sky130_fd_sc_hd__dlygate4sd3_1
Xhold827 _6785_/Q VGND VGND VPWR VPWR _6785_/D sky130_fd_sc_hd__dlygate4sd3_1
X_3532_ _3371_/A _3509_/Y _5642_/B _5659_/A _3958_/S VGND VGND VPWR VPWR _3621_/A
+ sky130_fd_sc_hd__a41o_2
XTAP_TAPCELL_ROW_116_1658 VGND VPWR sky130_fd_sc_hd__tapvpwrvgnd_1
XTAP_TAPCELL_ROW_116_1647 VGND VPWR sky130_fd_sc_hd__tapvpwrvgnd_1
XFILLER_6_381 VGND VGND VPWR VPWR sky130_fd_sc_hd__decap_3
Xhold838 _6806_/Q VGND VGND VPWR VPWR _6806_/D sky130_fd_sc_hd__dlygate4sd3_1
Xhold849 _7085_/Q VGND VGND VPWR VPWR _7085_/D sky130_fd_sc_hd__dlygate4sd3_1
Xmax_cap557 _4647_/C VGND VGND VPWR VPWR _4795_/A sky130_fd_sc_hd__buf_2
X_3463_ _7057_/Q _3577_/B _3590_/A _3462_/X VGND VGND VPWR VPWR _3545_/A sky130_fd_sc_hd__o211ai_4
XFILLER_69_333 VGND VGND VPWR VPWR sky130_fd_sc_hd__decap_3
X_3394_ _3394_/A _3429_/B VGND VGND VPWR VPWR _4305_/B sky130_fd_sc_hd__or2_2
XFILLER_111_452 VGND VGND VPWR VPWR sky130_fd_sc_hd__decap_3
XFILLER_29_208 VGND VGND VPWR VPWR sky130_fd_sc_hd__decap_3
XFILLER_69_355 VGND VGND VPWR VPWR sky130_fd_sc_hd__decap_3
XFILLER_96_141 VGND VGND VPWR VPWR sky130_fd_sc_hd__decap_3
XFILLER_57_539 VGND VGND VPWR VPWR sky130_fd_sc_hd__decap_3
XFILLER_69_388 VGND VGND VPWR VPWR sky130_fd_sc_hd__decap_3
XFILLER_52_200 VGND VGND VPWR VPWR sky130_fd_sc_hd__fill_2
XFILLER_65_561 VGND VGND VPWR VPWR sky130_fd_sc_hd__decap_3
XFILLER_16_27 VGND VGND VPWR VPWR sky130_fd_sc_hd__fill_1
XFILLER_16_38 VGND VGND VPWR VPWR sky130_fd_sc_hd__decap_3
XFILLER_25_436 VGND VGND VPWR VPWR sky130_fd_sc_hd__decap_3
XFILLER_52_233 VGND VGND VPWR VPWR sky130_fd_sc_hd__decap_3
XFILLER_80_542 VGND VGND VPWR VPWR sky130_fd_sc_hd__decap_3
XFILLER_13_609 VGND VGND VPWR VPWR sky130_fd_sc_hd__decap_3
XFILLER_40_417 VGND VGND VPWR VPWR sky130_fd_sc_hd__decap_3
XFILLER_21_620 VGND VGND VPWR VPWR sky130_fd_sc_hd__fill_2
XFILLER_80_597 VGND VGND VPWR VPWR sky130_fd_sc_hd__decap_3
X_4917_ _4967_/A _4950_/A _4967_/B VGND VGND VPWR VPWR _4918_/B sky130_fd_sc_hd__and3_2
XFILLER_20_141 VGND VGND VPWR VPWR sky130_fd_sc_hd__decap_3
X_4848_ _4884_/A _4904_/B _4140_/X VGND VGND VPWR VPWR _4872_/B sky130_fd_sc_hd__o21ba_2
XFILLER_20_174 VGND VGND VPWR VPWR sky130_fd_sc_hd__decap_3
XFILLER_32_59 VGND VGND VPWR VPWR sky130_fd_sc_hd__decap_3
X_4779_ _4779_/A _4827_/B VGND VGND VPWR VPWR _4779_/X sky130_fd_sc_hd__or2_2
X_6518_ _6675_/A VGND VGND VPWR VPWR _6518_/Y sky130_fd_sc_hd__inv_2
XFILLER_106_235 VGND VGND VPWR VPWR sky130_fd_sc_hd__decap_3
XFILLER_106_6 VGND VGND VPWR VPWR sky130_fd_sc_hd__decap_3
X_6449_ _6611_/A VGND VGND VPWR VPWR _6449_/Y sky130_fd_sc_hd__inv_2
XFILLER_0_502 VGND VGND VPWR VPWR sky130_fd_sc_hd__fill_2
XFILLER_106_268 VGND VGND VPWR VPWR sky130_fd_sc_hd__fill_1
XFILLER_79_119 VGND VGND VPWR VPWR sky130_fd_sc_hd__decap_3
XFILLER_0_524 VGND VGND VPWR VPWR sky130_fd_sc_hd__decap_3
XFILLER_0_546 VGND VGND VPWR VPWR sky130_fd_sc_hd__decap_3
XFILLER_102_430 VGND VGND VPWR VPWR sky130_fd_sc_hd__decap_3
XFILLER_88_642 VGND VGND VPWR VPWR sky130_fd_sc_hd__fill_2
XFILLER_88_675 VGND VGND VPWR VPWR sky130_fd_sc_hd__decap_3
XFILLER_102_474 VGND VGND VPWR VPWR sky130_fd_sc_hd__fill_2
XFILLER_48_528 VGND VGND VPWR VPWR sky130_fd_sc_hd__decap_3
XFILLER_57_45 VGND VGND VPWR VPWR sky130_fd_sc_hd__decap_3
XFILLER_57_78 VGND VGND VPWR VPWR sky130_fd_sc_hd__decap_3
XFILLER_113_51 VGND VGND VPWR VPWR sky130_fd_sc_hd__decap_3
XFILLER_28_274 VGND VGND VPWR VPWR sky130_fd_sc_hd__decap_3
XFILLER_90_328 VGND VGND VPWR VPWR sky130_fd_sc_hd__fill_2
XFILLER_90_339 VGND VGND VPWR VPWR sky130_fd_sc_hd__decap_3
XFILLER_113_84 VGND VGND VPWR VPWR sky130_fd_sc_hd__decap_3
XFILLER_28_285 VGND VGND VPWR VPWR sky130_fd_sc_hd__decap_3
XFILLER_71_520 VGND VGND VPWR VPWR sky130_fd_sc_hd__decap_3
XFILLER_73_33 VGND VGND VPWR VPWR sky130_fd_sc_hd__decap_3
XFILLER_73_55 VGND VGND VPWR VPWR sky130_fd_sc_hd__fill_1
XFILLER_43_244 VGND VGND VPWR VPWR sky130_fd_sc_hd__decap_3
XFILLER_71_597 VGND VGND VPWR VPWR sky130_fd_sc_hd__decap_3
XFILLER_12_653 VGND VGND VPWR VPWR sky130_fd_sc_hd__fill_2
XTAP_TAPCELL_ROW_100_1448 VGND VPWR sky130_fd_sc_hd__tapvpwrvgnd_1
XFILLER_11_152 VGND VGND VPWR VPWR sky130_fd_sc_hd__fill_1
XFILLER_7_134 VGND VGND VPWR VPWR sky130_fd_sc_hd__decap_3
XFILLER_8_679 VGND VGND VPWR VPWR sky130_fd_sc_hd__decap_3
XFILLER_7_167 VGND VGND VPWR VPWR sky130_fd_sc_hd__fill_1
XFILLER_3_340 VGND VGND VPWR VPWR sky130_fd_sc_hd__fill_2
XFILLER_3_384 VGND VGND VPWR VPWR sky130_fd_sc_hd__decap_3
XFILLER_98_96 VGND VGND VPWR VPWR sky130_fd_sc_hd__decap_3
XFILLER_21_6 VGND VGND VPWR VPWR sky130_fd_sc_hd__decap_3
XFILLER_79_653 VGND VGND VPWR VPWR sky130_fd_sc_hd__fill_2
XFILLER_79_664 VGND VGND VPWR VPWR sky130_fd_sc_hd__decap_3
XTAP_TAPCELL_ROW_111_1588 VGND VPWR sky130_fd_sc_hd__tapvpwrvgnd_1
XFILLER_93_100 VGND VGND VPWR VPWR sky130_fd_sc_hd__decap_3
XFILLER_93_111 VGND VGND VPWR VPWR sky130_fd_sc_hd__fill_1
XFILLER_93_122 VGND VGND VPWR VPWR sky130_fd_sc_hd__decap_3
XFILLER_94_623 VGND VGND VPWR VPWR sky130_fd_sc_hd__decap_3
XFILLER_94_645 VGND VGND VPWR VPWR sky130_fd_sc_hd__decap_3
XFILLER_66_347 VGND VGND VPWR VPWR sky130_fd_sc_hd__decap_3
XFILLER_93_155 VGND VGND VPWR VPWR sky130_fd_sc_hd__fill_1
XFILLER_94_678 VGND VGND VPWR VPWR sky130_fd_sc_hd__decap_3
XFILLER_19_274 VGND VGND VPWR VPWR sky130_fd_sc_hd__decap_3
XFILLER_34_200 VGND VGND VPWR VPWR sky130_fd_sc_hd__decap_3
XFILLER_47_561 VGND VGND VPWR VPWR sky130_fd_sc_hd__fill_2
XFILLER_47_583 VGND VGND VPWR VPWR sky130_fd_sc_hd__decap_3
XFILLER_34_233 VGND VGND VPWR VPWR sky130_fd_sc_hd__decap_3
XFILLER_74_380 VGND VGND VPWR VPWR sky130_fd_sc_hd__decap_3
XTAP_TAPCELL_ROW_66_1045 VGND VPWR sky130_fd_sc_hd__tapvpwrvgnd_1
XTAP_TAPCELL_ROW_17_453 VGND VPWR sky130_fd_sc_hd__tapvpwrvgnd_1
XFILLER_34_277 VGND VGND VPWR VPWR sky130_fd_sc_hd__decap_3
XTAP_TAPCELL_ROW_45_795 VGND VPWR sky130_fd_sc_hd__tapvpwrvgnd_1
XPHY_EDGE_ROW_22_Left_139 VGND VGND VPWR VPWR sky130_fd_sc_hd__decap_3
X_4702_ _6991_/Q _5026_/A VGND VGND VPWR VPWR _5001_/A sky130_fd_sc_hd__and2_2
XFILLER_30_450 VGND VGND VPWR VPWR sky130_fd_sc_hd__decap_3
XFILLER_8_50 VGND VGND VPWR VPWR sky130_fd_sc_hd__decap_3
X_5682_ _7347_/Q hold946/X _5708_/S VGND VGND VPWR VPWR _6691_/D sky130_fd_sc_hd__mux2_2
XFILLER_8_83 VGND VGND VPWR VPWR sky130_fd_sc_hd__fill_1
XFILLER_8_94 VGND VGND VPWR VPWR sky130_fd_sc_hd__decap_3
X_4633_ _4633_/A _4903_/A _4845_/A _4890_/B VGND VGND VPWR VPWR _4633_/X sky130_fd_sc_hd__or4_2
XFILLER_116_522 VGND VGND VPWR VPWR sky130_fd_sc_hd__decap_3
X_7352_ clkload6/A _7352_/D _6632_/Y VGND VGND VPWR VPWR _7352_/Q sky130_fd_sc_hd__dfrtp_2
Xhold602 _6885_/Q VGND VGND VPWR VPWR _6885_/D sky130_fd_sc_hd__dlygate4sd3_1
XFILLER_116_533 VGND VGND VPWR VPWR sky130_fd_sc_hd__fill_1
X_7283_ clkload5/A _7283_/D _6563_/Y VGND VGND VPWR VPWR _7283_/Q sky130_fd_sc_hd__dfrtp_2
Xhold613 _6767_/Q VGND VGND VPWR VPWR _6767_/D sky130_fd_sc_hd__dlygate4sd3_1
Xhold624 _6926_/Q VGND VGND VPWR VPWR _6926_/D sky130_fd_sc_hd__dlygate4sd3_1
Xhold635 _6763_/Q VGND VGND VPWR VPWR _6763_/D sky130_fd_sc_hd__dlygate4sd3_1
X_6303_ _6611_/A VGND VGND VPWR VPWR _6303_/Y sky130_fd_sc_hd__inv_2
X_3515_ _3509_/Y _3510_/X _4419_/B1 VGND VGND VPWR VPWR _4938_/A sky130_fd_sc_hd__a21o_2
XTAP_TAPCELL_ROW_77_1174 VGND VPWR sky130_fd_sc_hd__tapvpwrvgnd_1
XFILLER_116_577 VGND VGND VPWR VPWR sky130_fd_sc_hd__decap_3
XFILLER_89_417 VGND VGND VPWR VPWR sky130_fd_sc_hd__decap_3
Xhold646 _6788_/Q VGND VGND VPWR VPWR _6788_/D sky130_fd_sc_hd__dlygate4sd3_1
Xhold657 _6883_/Q VGND VGND VPWR VPWR _6883_/D sky130_fd_sc_hd__dlygate4sd3_1
Xhold668 _6842_/Q VGND VGND VPWR VPWR _6842_/D sky130_fd_sc_hd__dlygate4sd3_1
Xhold679 _6787_/Q VGND VGND VPWR VPWR _6787_/D sky130_fd_sc_hd__dlygate4sd3_1
X_4495_ _4495_/A0 _7300_/Q _4505_/S VGND VGND VPWR VPWR _4495_/X sky130_fd_sc_hd__mux2_2
XPHY_EDGE_ROW_31_Left_148 VGND VGND VPWR VPWR sky130_fd_sc_hd__decap_3
XFILLER_103_238 VGND VGND VPWR VPWR sky130_fd_sc_hd__decap_3
XTAP_TAPCELL_ROW_90_1330 VGND VPWR sky130_fd_sc_hd__tapvpwrvgnd_1
X_3377_ _3394_/A _3373_/X _5641_/A _5161_/A VGND VGND VPWR VPWR _3377_/X sky130_fd_sc_hd__and4bb_4
XFILLER_85_623 VGND VGND VPWR VPWR sky130_fd_sc_hd__fill_2
XFILLER_85_634 VGND VGND VPWR VPWR sky130_fd_sc_hd__decap_3
XFILLER_97_494 VGND VGND VPWR VPWR sky130_fd_sc_hd__fill_2
X_5116_ _5110_/Y _5111_/X _5115_/X VGND VGND VPWR VPWR _5658_/D sky130_fd_sc_hd__o21ai_4
XFILLER_111_293 VGND VGND VPWR VPWR sky130_fd_sc_hd__fill_2
XFILLER_57_358 VGND VGND VPWR VPWR sky130_fd_sc_hd__decap_3
XFILLER_85_667 VGND VGND VPWR VPWR sky130_fd_sc_hd__decap_3
X_5047_ _5114_/B _4617_/B _4617_/C _5100_/A VGND VGND VPWR VPWR _5084_/B sky130_fd_sc_hd__o31ai_2
XFILLER_25_200 VGND VGND VPWR VPWR sky130_fd_sc_hd__decap_3
XFILLER_27_37 VGND VGND VPWR VPWR sky130_fd_sc_hd__decap_3
XFILLER_38_550 VGND VGND VPWR VPWR sky130_fd_sc_hd__decap_3
XFILLER_25_233 VGND VGND VPWR VPWR sky130_fd_sc_hd__decap_3
X_6998_ _7341_/CLK _6998_/D _6278_/Y VGND VGND VPWR VPWR _6998_/Q sky130_fd_sc_hd__dfrtp_2
XPHY_EDGE_ROW_40_Left_157 VGND VGND VPWR VPWR sky130_fd_sc_hd__decap_3
XFILLER_40_269 VGND VGND VPWR VPWR sky130_fd_sc_hd__decap_3
XFILLER_43_69 VGND VGND VPWR VPWR sky130_fd_sc_hd__decap_3
XFILLER_5_605 VGND VGND VPWR VPWR sky130_fd_sc_hd__decap_3
XFILLER_4_115 VGND VGND VPWR VPWR sky130_fd_sc_hd__decap_3
XFILLER_104_3 VGND VGND VPWR VPWR sky130_fd_sc_hd__decap_3
XFILLER_5_649 VGND VGND VPWR VPWR sky130_fd_sc_hd__decap_3
XFILLER_108_62 VGND VGND VPWR VPWR sky130_fd_sc_hd__decap_3
XFILLER_4_159 VGND VGND VPWR VPWR sky130_fd_sc_hd__fill_1
XFILLER_68_11 VGND VGND VPWR VPWR sky130_fd_sc_hd__decap_3
XFILLER_0_332 VGND VGND VPWR VPWR sky130_fd_sc_hd__decap_3
XFILLER_68_66 VGND VGND VPWR VPWR sky130_fd_sc_hd__decap_3
XFILLER_0_365 VGND VGND VPWR VPWR sky130_fd_sc_hd__decap_3
XFILLER_102_271 VGND VGND VPWR VPWR sky130_fd_sc_hd__fill_2
XFILLER_48_303 VGND VGND VPWR VPWR sky130_fd_sc_hd__decap_3
XFILLER_48_325 VGND VGND VPWR VPWR sky130_fd_sc_hd__decap_3
XFILLER_68_88 VGND VGND VPWR VPWR sky130_fd_sc_hd__decap_3
XFILLER_76_634 VGND VGND VPWR VPWR sky130_fd_sc_hd__decap_3
XFILLER_75_122 VGND VGND VPWR VPWR sky130_fd_sc_hd__decap_3
XFILLER_76_645 VGND VGND VPWR VPWR sky130_fd_sc_hd__decap_3
XFILLER_76_678 VGND VGND VPWR VPWR sky130_fd_sc_hd__decap_3
XFILLER_84_32 VGND VGND VPWR VPWR sky130_fd_sc_hd__decap_3
XFILLER_75_166 VGND VGND VPWR VPWR sky130_fd_sc_hd__fill_2
XFILLER_84_65 VGND VGND VPWR VPWR sky130_fd_sc_hd__decap_3
XFILLER_90_103 VGND VGND VPWR VPWR sky130_fd_sc_hd__decap_3
XFILLER_16_200 VGND VGND VPWR VPWR sky130_fd_sc_hd__decap_3
XFILLER_44_531 VGND VGND VPWR VPWR sky130_fd_sc_hd__fill_1
Xplace328 _5721_/S VGND VGND VPWR VPWR _5737_/S sky130_fd_sc_hd__buf_2
Xplace317 _3424_/S VGND VGND VPWR VPWR _4327_/A sky130_fd_sc_hd__buf_2
Xplace306 _3586_/Y VGND VGND VPWR VPWR _3600_/A sky130_fd_sc_hd__buf_2
XFILLER_44_575 VGND VGND VPWR VPWR sky130_fd_sc_hd__decap_3
Xplace339 _5396_/S VGND VGND VPWR VPWR _5417_/S sky130_fd_sc_hd__buf_2
XFILLER_16_288 VGND VGND VPWR VPWR sky130_fd_sc_hd__decap_3
XFILLER_31_214 VGND VGND VPWR VPWR sky130_fd_sc_hd__decap_3
XFILLER_31_247 VGND VGND VPWR VPWR sky130_fd_sc_hd__decap_3
XTAP_TAPCELL_ROW_42_754 VGND VPWR sky130_fd_sc_hd__tapvpwrvgnd_1
XTAP_TAPCELL_ROW_14_423 VGND VPWR sky130_fd_sc_hd__tapvpwrvgnd_1
XFILLER_69_6 VGND VGND VPWR VPWR sky130_fd_sc_hd__decap_3
XTAP_TAPCELL_ROW_113_1606 VGND VPWR sky130_fd_sc_hd__tapvpwrvgnd_1
XFILLER_4_660 VGND VGND VPWR VPWR sky130_fd_sc_hd__decap_3
X_3300_ _3403_/A VGND VGND VPWR VPWR _4467_/A sky130_fd_sc_hd__inv_2
X_4280_ _7222_/Q _4340_/A2 _4339_/B1 _7158_/Q _4279_/X VGND VGND VPWR VPWR _4280_/X
+ sky130_fd_sc_hd__a221o_2
XFILLER_113_558 VGND VGND VPWR VPWR sky130_fd_sc_hd__fill_2
XFILLER_67_601 VGND VGND VPWR VPWR sky130_fd_sc_hd__decap_3
XFILLER_98_269 VGND VGND VPWR VPWR sky130_fd_sc_hd__fill_1
XFILLER_94_475 VGND VGND VPWR VPWR sky130_fd_sc_hd__fill_1
XFILLER_94_486 VGND VGND VPWR VPWR sky130_fd_sc_hd__fill_1
XFILLER_81_125 VGND VGND VPWR VPWR sky130_fd_sc_hd__decap_3
XFILLER_82_648 VGND VGND VPWR VPWR sky130_fd_sc_hd__decap_3
X_6921_ _6977_/CLK _6921_/D VGND VGND VPWR VPWR _6921_/Q sky130_fd_sc_hd__dfxtp_2
X_6852_ _6959_/CLK _6852_/D VGND VGND VPWR VPWR _6852_/Q sky130_fd_sc_hd__dfxtp_2
XFILLER_22_203 VGND VGND VPWR VPWR sky130_fd_sc_hd__decap_3
XFILLER_35_586 VGND VGND VPWR VPWR sky130_fd_sc_hd__decap_3
XFILLER_62_394 VGND VGND VPWR VPWR sky130_fd_sc_hd__decap_3
XFILLER_90_670 VGND VGND VPWR VPWR sky130_fd_sc_hd__decap_3
Xfanout18 _6540_/A VGND VGND VPWR VPWR _6539_/A sky130_fd_sc_hd__buf_2
Xfanout29 _6536_/A VGND VGND VPWR VPWR _6600_/A sky130_fd_sc_hd__clkdlybuf4s25_1
XFILLER_22_236 VGND VGND VPWR VPWR sky130_fd_sc_hd__decap_3
XFILLER_22_247 VGND VGND VPWR VPWR sky130_fd_sc_hd__decap_3
X_6783_ _7387_/CLK _6783_/D VGND VGND VPWR VPWR _6783_/Q sky130_fd_sc_hd__dfxtp_2
XFILLER_13_17 VGND VGND VPWR VPWR sky130_fd_sc_hd__decap_3
XFILLER_50_578 VGND VGND VPWR VPWR sky130_fd_sc_hd__decap_3
X_5665_ _5665_/A _5665_/B _5665_/C _5665_/D VGND VGND VPWR VPWR _5666_/B sky130_fd_sc_hd__and4_2
XTAP_TAPCELL_ROW_79_1203 VGND VPWR sky130_fd_sc_hd__tapvpwrvgnd_1
X_7404_ _7406_/CLK _7404_/D _6684_/Y VGND VGND VPWR VPWR _7404_/Q sky130_fd_sc_hd__dfrtp_2
X_4616_ _3547_/A _3547_/B _4614_/X _4615_/Y VGND VGND VPWR VPWR _4617_/C sky130_fd_sc_hd__a31o_2
X_7335_ _7369_/CLK _7335_/D _6615_/Y VGND VGND VPWR VPWR _7335_/Q sky130_fd_sc_hd__dfrtp_2
XPHY_EDGE_ROW_111_Right_111 VGND VGND VPWR VPWR sky130_fd_sc_hd__decap_3
XFILLER_104_503 VGND VGND VPWR VPWR sky130_fd_sc_hd__decap_3
XFILLER_89_203 VGND VGND VPWR VPWR sky130_fd_sc_hd__fill_2
XFILLER_116_385 VGND VGND VPWR VPWR sky130_fd_sc_hd__decap_3
XFILLER_116_396 VGND VGND VPWR VPWR sky130_fd_sc_hd__decap_3
XFILLER_89_214 VGND VGND VPWR VPWR sky130_fd_sc_hd__decap_3
XFILLER_89_225 VGND VGND VPWR VPWR sky130_fd_sc_hd__decap_3
X_7266_ _7266_/CLK _7266_/D _6546_/Y VGND VGND VPWR VPWR _7266_/Q sky130_fd_sc_hd__dfrtp_2
X_4478_ _4478_/A0 _4544_/A _4478_/S VGND VGND VPWR VPWR _7340_/D sky130_fd_sc_hd__mux2_2
XFILLER_104_569 VGND VGND VPWR VPWR sky130_fd_sc_hd__fill_1
XFILLER_89_258 VGND VGND VPWR VPWR sky130_fd_sc_hd__decap_3
X_7197_ _7392_/CLK _7197_/D _6477_/Y VGND VGND VPWR VPWR _7197_/Q sky130_fd_sc_hd__dfrtp_2
X_3429_ _3429_/A _3429_/B VGND VGND VPWR VPWR _3590_/A sky130_fd_sc_hd__or2_2
XFILLER_58_612 VGND VGND VPWR VPWR sky130_fd_sc_hd__decap_3
XFILLER_85_420 VGND VGND VPWR VPWR sky130_fd_sc_hd__decap_3
XFILLER_57_144 VGND VGND VPWR VPWR sky130_fd_sc_hd__decap_3
XFILLER_58_645 VGND VGND VPWR VPWR sky130_fd_sc_hd__decap_3
Xhold1110 _7138_/Q VGND VGND VPWR VPWR _5390_/A0 sky130_fd_sc_hd__dlygate4sd3_1
Xhold1121 _7264_/Q VGND VGND VPWR VPWR _4965_/A0 sky130_fd_sc_hd__dlygate4sd3_1
Xhold1132 _7189_/Q VGND VGND VPWR VPWR _5282_/A1 sky130_fd_sc_hd__dlygate4sd3_1
XFILLER_45_317 VGND VGND VPWR VPWR sky130_fd_sc_hd__decap_3
XFILLER_57_177 VGND VGND VPWR VPWR sky130_fd_sc_hd__decap_3
XFILLER_58_678 VGND VGND VPWR VPWR sky130_fd_sc_hd__decap_3
XFILLER_73_626 VGND VGND VPWR VPWR sky130_fd_sc_hd__decap_3
Xhold1143 _7178_/Q VGND VGND VPWR VPWR _5304_/A0 sky130_fd_sc_hd__dlygate4sd3_1
Xhold1154 _7146_/Q VGND VGND VPWR VPWR _5373_/A0 sky130_fd_sc_hd__dlygate4sd3_1
Xhold1165 _7306_/Q VGND VGND VPWR VPWR _4548_/A sky130_fd_sc_hd__dlygate4sd3_1
Xhold1176 _7322_/Q VGND VGND VPWR VPWR _4515_/A0 sky130_fd_sc_hd__dlygate4sd3_1
XFILLER_38_380 VGND VGND VPWR VPWR sky130_fd_sc_hd__decap_3
XFILLER_85_497 VGND VGND VPWR VPWR sky130_fd_sc_hd__decap_3
Xhold1187 _7151_/Q VGND VGND VPWR VPWR _5360_/A0 sky130_fd_sc_hd__dlygate4sd3_1
Xhold1198 _7163_/Q VGND VGND VPWR VPWR _5336_/A0 sky130_fd_sc_hd__dlygate4sd3_1
XFILLER_54_24 VGND VGND VPWR VPWR sky130_fd_sc_hd__decap_3
XFILLER_54_35 VGND VGND VPWR VPWR sky130_fd_sc_hd__decap_3
XFILLER_60_309 VGND VGND VPWR VPWR sky130_fd_sc_hd__decap_3
XFILLER_13_214 VGND VGND VPWR VPWR sky130_fd_sc_hd__decap_3
XFILLER_41_501 VGND VGND VPWR VPWR sky130_fd_sc_hd__decap_3
XFILLER_54_68 VGND VGND VPWR VPWR sky130_fd_sc_hd__decap_3
XFILLER_81_670 VGND VGND VPWR VPWR sky130_fd_sc_hd__fill_2
XFILLER_110_41 VGND VGND VPWR VPWR sky130_fd_sc_hd__decap_3
XFILLER_13_258 VGND VGND VPWR VPWR sky130_fd_sc_hd__decap_3
XFILLER_80_180 VGND VGND VPWR VPWR sky130_fd_sc_hd__decap_3
XFILLER_110_74 VGND VGND VPWR VPWR sky130_fd_sc_hd__decap_3
XFILLER_110_85 VGND VGND VPWR VPWR sky130_fd_sc_hd__decap_3
XFILLER_70_12 VGND VGND VPWR VPWR sky130_fd_sc_hd__decap_3
XFILLER_70_67 VGND VGND VPWR VPWR sky130_fd_sc_hd__decap_3
XFILLER_5_413 VGND VGND VPWR VPWR sky130_fd_sc_hd__decap_3
XFILLER_107_363 VGND VGND VPWR VPWR sky130_fd_sc_hd__fill_2
XFILLER_5_457 VGND VGND VPWR VPWR sky130_fd_sc_hd__decap_3
XFILLER_107_374 VGND VGND VPWR VPWR sky130_fd_sc_hd__decap_3
XFILLER_79_87 VGND VGND VPWR VPWR sky130_fd_sc_hd__decap_3
XFILLER_1_641 VGND VGND VPWR VPWR sky130_fd_sc_hd__decap_3
XFILLER_49_623 VGND VGND VPWR VPWR sky130_fd_sc_hd__decap_3
XFILLER_0_195 VGND VGND VPWR VPWR sky130_fd_sc_hd__fill_1
XFILLER_48_144 VGND VGND VPWR VPWR sky130_fd_sc_hd__decap_3
XFILLER_49_656 VGND VGND VPWR VPWR sky130_fd_sc_hd__decap_3
XFILLER_95_53 VGND VGND VPWR VPWR sky130_fd_sc_hd__decap_3
XFILLER_95_75 VGND VGND VPWR VPWR sky130_fd_sc_hd__fill_1
XFILLER_48_177 VGND VGND VPWR VPWR sky130_fd_sc_hd__decap_3
XFILLER_76_475 VGND VGND VPWR VPWR sky130_fd_sc_hd__fill_1
XTAP_TAPCELL_ROW_47_813 VGND VPWR sky130_fd_sc_hd__tapvpwrvgnd_1
XFILLER_28_91 VGND VGND VPWR VPWR sky130_fd_sc_hd__decap_3
XFILLER_64_637 VGND VGND VPWR VPWR sky130_fd_sc_hd__decap_3
XFILLER_64_648 VGND VGND VPWR VPWR sky130_fd_sc_hd__decap_3
XFILLER_91_423 VGND VGND VPWR VPWR sky130_fd_sc_hd__decap_3
XFILLER_63_147 VGND VGND VPWR VPWR sky130_fd_sc_hd__decap_3
XFILLER_32_512 VGND VGND VPWR VPWR sky130_fd_sc_hd__decap_3
XFILLER_72_681 VGND VGND VPWR VPWR sky130_fd_sc_hd__decap_3
XTAP_TAPCELL_ROW_63_1004 VGND VPWR sky130_fd_sc_hd__tapvpwrvgnd_1
XTAP_TAPCELL_ROW_27_570 VGND VPWR sky130_fd_sc_hd__tapvpwrvgnd_1
XFILLER_71_191 VGND VGND VPWR VPWR sky130_fd_sc_hd__fill_2
XTAP_TAPCELL_ROW_27_581 VGND VPWR sky130_fd_sc_hd__tapvpwrvgnd_1
X_3780_ _6967_/Q _3886_/A2 _3651_/Y _6955_/Q VGND VGND VPWR VPWR _3780_/X sky130_fd_sc_hd__a22o_2
XFILLER_67_3 VGND VGND VPWR VPWR sky130_fd_sc_hd__decap_3
XFILLER_8_295 VGND VGND VPWR VPWR sky130_fd_sc_hd__fill_2
X_4401_ _7274_/Q _4408_/A2 _4430_/A2 _7242_/Q _4400_/X VGND VGND VPWR VPWR _4401_/X
+ sky130_fd_sc_hd__a221o_2
Xoutput526 _6992_/Q VGND VGND VPWR VPWR pc_out[15] sky130_fd_sc_hd__clkdlybuf4s25_1
Xoutput515 _5643_/X VGND VGND VPWR VPWR instruction_out[5] sky130_fd_sc_hd__clkdlybuf4s25_1
Xoutput504 _3449_/A VGND VGND VPWR VPWR instruction_out[22] sky130_fd_sc_hd__clkdlybuf4s25_1
X_5381_ _5381_/A0 _4864_/X _5383_/S VGND VGND VPWR VPWR _7142_/D sky130_fd_sc_hd__mux2_2
XFILLER_113_311 VGND VGND VPWR VPWR sky130_fd_sc_hd__decap_3
XFILLER_5_51 VGND VGND VPWR VPWR sky130_fd_sc_hd__decap_3
X_7120_ _7356_/CLK _7120_/D _6400_/Y VGND VGND VPWR VPWR _7120_/Q sky130_fd_sc_hd__dfrtp_2
Xoutput548 _6983_/Q VGND VGND VPWR VPWR pc_out[6] sky130_fd_sc_hd__clkdlybuf4s25_1
Xoutput537 _7002_/Q VGND VGND VPWR VPWR pc_out[25] sky130_fd_sc_hd__clkdlybuf4s25_1
X_4332_ _7191_/Q _3996_/S _4332_/B1 _7383_/Q _4331_/X VGND VGND VPWR VPWR _4332_/X
+ sky130_fd_sc_hd__a221o_2
XTAP_TAPCELL_ROW_74_1144 VGND VPWR sky130_fd_sc_hd__tapvpwrvgnd_1
XFILLER_99_534 VGND VGND VPWR VPWR sky130_fd_sc_hd__decap_3
XFILLER_5_84 VGND VGND VPWR VPWR sky130_fd_sc_hd__decap_3
X_7051_ _7401_/CLK _7051_/D _6331_/Y VGND VGND VPWR VPWR _7051_/Q sky130_fd_sc_hd__dfrtp_2
X_4263_ _7134_/Q _5229_/C _4261_/X _4262_/X VGND VGND VPWR VPWR _4264_/B sky130_fd_sc_hd__a211o_2
XFILLER_99_578 VGND VGND VPWR VPWR sky130_fd_sc_hd__decap_3
XFILLER_101_517 VGND VGND VPWR VPWR sky130_fd_sc_hd__decap_3
XFILLER_113_388 VGND VGND VPWR VPWR sky130_fd_sc_hd__decap_3
XFILLER_86_217 VGND VGND VPWR VPWR sky130_fd_sc_hd__decap_3
XFILLER_86_239 VGND VGND VPWR VPWR sky130_fd_sc_hd__decap_3
XPHY_EDGE_ROW_105_Left_222 VGND VGND VPWR VPWR sky130_fd_sc_hd__decap_3
XFILLER_39_111 VGND VGND VPWR VPWR sky130_fd_sc_hd__fill_1
XFILLER_39_122 VGND VGND VPWR VPWR sky130_fd_sc_hd__decap_3
X_4194_ _7231_/Q _3318_/B _4422_/A2 _7017_/Q _4193_/X VGND VGND VPWR VPWR _4194_/X
+ sky130_fd_sc_hd__a221o_2
XFILLER_39_155 VGND VGND VPWR VPWR sky130_fd_sc_hd__fill_1
XFILLER_55_615 VGND VGND VPWR VPWR sky130_fd_sc_hd__fill_1
XFILLER_55_626 VGND VGND VPWR VPWR sky130_fd_sc_hd__decap_3
XFILLER_82_401 VGND VGND VPWR VPWR sky130_fd_sc_hd__decap_3
XFILLER_54_103 VGND VGND VPWR VPWR sky130_fd_sc_hd__decap_3
XFILLER_55_659 VGND VGND VPWR VPWR sky130_fd_sc_hd__decap_3
XFILLER_94_283 VGND VGND VPWR VPWR sky130_fd_sc_hd__decap_3
XFILLER_54_147 VGND VGND VPWR VPWR sky130_fd_sc_hd__decap_3
X_6904_ _6959_/CLK _6904_/D VGND VGND VPWR VPWR _6904_/Q sky130_fd_sc_hd__dfxtp_2
XFILLER_23_523 VGND VGND VPWR VPWR sky130_fd_sc_hd__decap_3
XFILLER_82_489 VGND VGND VPWR VPWR sky130_fd_sc_hd__decap_3
XTAP_TAPCELL_ROW_85_1273 VGND VPWR sky130_fd_sc_hd__tapvpwrvgnd_1
XFILLER_24_38 VGND VGND VPWR VPWR sky130_fd_sc_hd__decap_3
X_6835_ _6975_/CLK _6835_/D VGND VGND VPWR VPWR _6835_/Q sky130_fd_sc_hd__dfxtp_2
X_6766_ _6965_/CLK _6766_/D VGND VGND VPWR VPWR _6766_/Q sky130_fd_sc_hd__dfxtp_2
XPHY_EDGE_ROW_114_Left_231 VGND VGND VPWR VPWR sky130_fd_sc_hd__decap_3
XFILLER_10_228 VGND VGND VPWR VPWR sky130_fd_sc_hd__decap_3
X_5717_ _7364_/Q hold915/X _5719_/S VGND VGND VPWR VPWR _6708_/D sky130_fd_sc_hd__mux2_2
XFILLER_109_617 VGND VGND VPWR VPWR sky130_fd_sc_hd__decap_3
X_6697_ _7392_/CLK _6697_/D VGND VGND VPWR VPWR _6697_/Q sky130_fd_sc_hd__dfxtp_2
X_5648_ _5648_/A _5648_/B VGND VGND VPWR VPWR _5649_/A sky130_fd_sc_hd__or2_2
X_5579_ _5579_/A0 _5045_/X _5581_/S VGND VGND VPWR VPWR _7039_/D sky130_fd_sc_hd__mux2_2
XFILLER_2_416 VGND VGND VPWR VPWR sky130_fd_sc_hd__decap_3
XFILLER_2_427 VGND VGND VPWR VPWR sky130_fd_sc_hd__decap_3
X_7318_ clkload6/A _7318_/D _6598_/Y VGND VGND VPWR VPWR _7318_/Q sky130_fd_sc_hd__dfrtp_2
XFILLER_116_193 VGND VGND VPWR VPWR sky130_fd_sc_hd__decap_3
XFILLER_49_46 VGND VGND VPWR VPWR sky130_fd_sc_hd__decap_3
X_7249_ _7322_/CLK _7249_/D _6529_/Y VGND VGND VPWR VPWR _7249_/Q sky130_fd_sc_hd__dfrtp_2
XFILLER_77_206 VGND VGND VPWR VPWR sky130_fd_sc_hd__decap_3
XFILLER_77_228 VGND VGND VPWR VPWR sky130_fd_sc_hd__decap_3
XFILLER_105_30 VGND VGND VPWR VPWR sky130_fd_sc_hd__decap_3
XFILLER_58_442 VGND VGND VPWR VPWR sky130_fd_sc_hd__decap_3
XFILLER_46_615 VGND VGND VPWR VPWR sky130_fd_sc_hd__decap_3
XFILLER_65_12 VGND VGND VPWR VPWR sky130_fd_sc_hd__decap_3
XFILLER_85_261 VGND VGND VPWR VPWR sky130_fd_sc_hd__decap_3
XFILLER_92_209 VGND VGND VPWR VPWR sky130_fd_sc_hd__fill_1
XFILLER_100_583 VGND VGND VPWR VPWR sky130_fd_sc_hd__decap_3
XFILLER_18_339 VGND VGND VPWR VPWR sky130_fd_sc_hd__decap_3
XFILLER_46_648 VGND VGND VPWR VPWR sky130_fd_sc_hd__decap_3
XFILLER_73_445 VGND VGND VPWR VPWR sky130_fd_sc_hd__decap_3
XFILLER_45_147 VGND VGND VPWR VPWR sky130_fd_sc_hd__decap_3
XFILLER_45_158 VGND VGND VPWR VPWR sky130_fd_sc_hd__decap_3
XFILLER_45_169 VGND VGND VPWR VPWR sky130_fd_sc_hd__decap_3
XFILLER_65_89 VGND VGND VPWR VPWR sky130_fd_sc_hd__decap_3
XFILLER_73_467 VGND VGND VPWR VPWR sky130_fd_sc_hd__decap_3
XFILLER_26_383 VGND VGND VPWR VPWR sky130_fd_sc_hd__fill_1
XFILLER_54_681 VGND VGND VPWR VPWR sky130_fd_sc_hd__decap_3
XFILLER_61_629 VGND VGND VPWR VPWR sky130_fd_sc_hd__decap_3
XFILLER_14_545 VGND VGND VPWR VPWR sky130_fd_sc_hd__decap_3
XFILLER_41_320 VGND VGND VPWR VPWR sky130_fd_sc_hd__decap_3
XFILLER_81_33 VGND VGND VPWR VPWR sky130_fd_sc_hd__decap_3
XFILLER_41_364 VGND VGND VPWR VPWR sky130_fd_sc_hd__decap_3
XFILLER_81_66 VGND VGND VPWR VPWR sky130_fd_sc_hd__decap_3
XTAP_TAPCELL_ROW_52_871 VGND VPWR sky130_fd_sc_hd__tapvpwrvgnd_1
XTAP_TAPCELL_ROW_24_540 VGND VPWR sky130_fd_sc_hd__tapvpwrvgnd_1
XFILLER_108_672 VGND VGND VPWR VPWR sky130_fd_sc_hd__decap_3
XFILLER_115_609 VGND VGND VPWR VPWR sky130_fd_sc_hd__decap_3
XFILLER_5_243 VGND VGND VPWR VPWR sky130_fd_sc_hd__fill_2
XFILLER_5_287 VGND VGND VPWR VPWR sky130_fd_sc_hd__decap_3
XFILLER_107_193 VGND VGND VPWR VPWR sky130_fd_sc_hd__decap_3
XFILLER_68_206 VGND VGND VPWR VPWR sky130_fd_sc_hd__decap_3
XFILLER_68_228 VGND VGND VPWR VPWR sky130_fd_sc_hd__decap_3
XFILLER_110_358 VGND VGND VPWR VPWR sky130_fd_sc_hd__decap_3
XFILLER_49_442 VGND VGND VPWR VPWR sky130_fd_sc_hd__fill_2
XFILLER_39_90 VGND VGND VPWR VPWR sky130_fd_sc_hd__fill_2
XFILLER_49_475 VGND VGND VPWR VPWR sky130_fd_sc_hd__fill_2
XFILLER_36_114 VGND VGND VPWR VPWR sky130_fd_sc_hd__decap_3
XFILLER_49_497 VGND VGND VPWR VPWR sky130_fd_sc_hd__decap_3
XFILLER_36_169 VGND VGND VPWR VPWR sky130_fd_sc_hd__decap_3
XFILLER_52_607 VGND VGND VPWR VPWR sky130_fd_sc_hd__decap_3
XTAP_TAPCELL_ROW_108_1549 VGND VPWR sky130_fd_sc_hd__tapvpwrvgnd_1
XFILLER_17_361 VGND VGND VPWR VPWR sky130_fd_sc_hd__decap_3
XFILLER_51_106 VGND VGND VPWR VPWR sky130_fd_sc_hd__decap_3
XFILLER_51_128 VGND VGND VPWR VPWR sky130_fd_sc_hd__fill_1
X_4950_ _4950_/A _4950_/B VGND VGND VPWR VPWR _4950_/Y sky130_fd_sc_hd__nor2_2
XFILLER_32_320 VGND VGND VPWR VPWR sky130_fd_sc_hd__decap_3
XFILLER_44_191 VGND VGND VPWR VPWR sky130_fd_sc_hd__decap_3
XFILLER_60_640 VGND VGND VPWR VPWR sky130_fd_sc_hd__decap_3
X_4881_ _6998_/Q _4912_/A VGND VGND VPWR VPWR _4882_/B sky130_fd_sc_hd__or2_2
X_3901_ _3901_/A1 _3909_/A2 _3900_/Y VGND VGND VPWR VPWR _7381_/D sky130_fd_sc_hd__a21bo_2
XFILLER_60_651 VGND VGND VPWR VPWR sky130_fd_sc_hd__decap_3
XFILLER_60_684 VGND VGND VPWR VPWR sky130_fd_sc_hd__decap_3
X_6620_ _6651_/A VGND VGND VPWR VPWR _6620_/Y sky130_fd_sc_hd__inv_2
X_3832_ _3728_/Y _3824_/X _3826_/X _3735_/X _3831_/X VGND VGND VPWR VPWR _3832_/X
+ sky130_fd_sc_hd__a221o_2
X_6551_ _6617_/A VGND VGND VPWR VPWR _6551_/Y sky130_fd_sc_hd__inv_2
XFILLER_20_559 VGND VGND VPWR VPWR sky130_fd_sc_hd__decap_3
X_3763_ _3763_/A1 _4466_/A _3762_/X VGND VGND VPWR VPWR _7395_/D sky130_fd_sc_hd__a21o_2
X_6482_ _6611_/A VGND VGND VPWR VPWR _6482_/Y sky130_fd_sc_hd__inv_2
XFILLER_10_18 VGND VGND VPWR VPWR sky130_fd_sc_hd__decap_3
XFILLER_10_29 VGND VGND VPWR VPWR sky130_fd_sc_hd__decap_3
XFILLER_114_631 VGND VGND VPWR VPWR sky130_fd_sc_hd__decap_3
XFILLER_99_320 VGND VGND VPWR VPWR sky130_fd_sc_hd__decap_3
X_7103_ _7365_/CLK _7103_/D _6383_/Y VGND VGND VPWR VPWR _7103_/Q sky130_fd_sc_hd__dfrtp_2
X_4315_ _4315_/A _4315_/B VGND VGND VPWR VPWR _4361_/A sky130_fd_sc_hd__nand2_2
XFILLER_101_314 VGND VGND VPWR VPWR sky130_fd_sc_hd__decap_3
XFILLER_113_152 VGND VGND VPWR VPWR sky130_fd_sc_hd__decap_3
XFILLER_114_675 VGND VGND VPWR VPWR sky130_fd_sc_hd__decap_3
XFILLER_59_217 VGND VGND VPWR VPWR sky130_fd_sc_hd__decap_3
XFILLER_87_526 VGND VGND VPWR VPWR sky130_fd_sc_hd__decap_3
XFILLER_99_375 VGND VGND VPWR VPWR sky130_fd_sc_hd__decap_3
XFILLER_113_196 VGND VGND VPWR VPWR sky130_fd_sc_hd__decap_3
XFILLER_19_38 VGND VGND VPWR VPWR sky130_fd_sc_hd__decap_3
X_7034_ _7384_/CLK _7034_/D _6314_/Y VGND VGND VPWR VPWR _7034_/Q sky130_fd_sc_hd__dfrtp_2
X_4246_ _7229_/Q _3377_/X _5229_/C _7133_/Q VGND VGND VPWR VPWR _4246_/X sky130_fd_sc_hd__a22o_2
XFILLER_101_369 VGND VGND VPWR VPWR sky130_fd_sc_hd__decap_3
XFILLER_67_250 VGND VGND VPWR VPWR sky130_fd_sc_hd__decap_3
XFILLER_95_570 VGND VGND VPWR VPWR sky130_fd_sc_hd__decap_3
X_4177_ _7232_/Q _3377_/X _4175_/X _4176_/X VGND VGND VPWR VPWR _4177_/X sky130_fd_sc_hd__a211o_2
XFILLER_28_648 VGND VGND VPWR VPWR sky130_fd_sc_hd__decap_3
XFILLER_27_147 VGND VGND VPWR VPWR sky130_fd_sc_hd__decap_3
XFILLER_82_242 VGND VGND VPWR VPWR sky130_fd_sc_hd__decap_3
XFILLER_82_253 VGND VGND VPWR VPWR sky130_fd_sc_hd__decap_3
XTAP_TAPCELL_ROW_2_279 VGND VPWR sky130_fd_sc_hd__tapvpwrvgnd_1
XFILLER_27_169 VGND VGND VPWR VPWR sky130_fd_sc_hd__decap_3
XFILLER_35_26 VGND VGND VPWR VPWR sky130_fd_sc_hd__decap_3
XFILLER_43_629 VGND VGND VPWR VPWR sky130_fd_sc_hd__decap_3
XFILLER_55_478 VGND VGND VPWR VPWR sky130_fd_sc_hd__fill_1
XFILLER_70_415 VGND VGND VPWR VPWR sky130_fd_sc_hd__decap_3
XFILLER_70_448 VGND VGND VPWR VPWR sky130_fd_sc_hd__decap_3
XFILLER_51_662 VGND VGND VPWR VPWR sky130_fd_sc_hd__decap_3
XFILLER_51_673 VGND VGND VPWR VPWR sky130_fd_sc_hd__decap_3
X_6818_ _6911_/CLK _6818_/D VGND VGND VPWR VPWR _6818_/Q sky130_fd_sc_hd__dfxtp_2
XFILLER_50_183 VGND VGND VPWR VPWR sky130_fd_sc_hd__decap_3
XFILLER_51_36 VGND VGND VPWR VPWR sky130_fd_sc_hd__decap_3
XFILLER_11_559 VGND VGND VPWR VPWR sky130_fd_sc_hd__fill_1
X_6749_ _6965_/CLK _6749_/D VGND VGND VPWR VPWR _6749_/Q sky130_fd_sc_hd__dfxtp_2
XTAP_TAPCELL_ROW_98_1431 VGND VPWR sky130_fd_sc_hd__tapvpwrvgnd_1
XFILLER_109_458 VGND VGND VPWR VPWR sky130_fd_sc_hd__decap_3
XFILLER_105_620 VGND VGND VPWR VPWR sky130_fd_sc_hd__decap_3
XFILLER_105_664 VGND VGND VPWR VPWR sky130_fd_sc_hd__decap_3
XFILLER_104_152 VGND VGND VPWR VPWR sky130_fd_sc_hd__fill_1
XFILLER_2_268 VGND VGND VPWR VPWR sky130_fd_sc_hd__decap_3
XFILLER_2_279 VGND VGND VPWR VPWR sky130_fd_sc_hd__fill_2
XFILLER_78_504 VGND VGND VPWR VPWR sky130_fd_sc_hd__decap_3
XFILLER_104_185 VGND VGND VPWR VPWR sky130_fd_sc_hd__decap_3
XFILLER_78_548 VGND VGND VPWR VPWR sky130_fd_sc_hd__decap_3
XFILLER_19_604 VGND VGND VPWR VPWR sky130_fd_sc_hd__decap_3
XFILLER_58_250 VGND VGND VPWR VPWR sky130_fd_sc_hd__fill_2
XFILLER_18_103 VGND VGND VPWR VPWR sky130_fd_sc_hd__decap_3
XFILLER_46_412 VGND VGND VPWR VPWR sky130_fd_sc_hd__decap_3
XFILLER_76_88 VGND VGND VPWR VPWR sky130_fd_sc_hd__decap_3
XFILLER_86_581 VGND VGND VPWR VPWR sky130_fd_sc_hd__decap_3
XFILLER_86_592 VGND VGND VPWR VPWR sky130_fd_sc_hd__decap_3
XTAP_TAPCELL_ROW_57_930 VGND VPWR sky130_fd_sc_hd__tapvpwrvgnd_1
XFILLER_18_136 VGND VGND VPWR VPWR sky130_fd_sc_hd__decap_3
XFILLER_18_147 VGND VGND VPWR VPWR sky130_fd_sc_hd__decap_3
XFILLER_46_467 VGND VGND VPWR VPWR sky130_fd_sc_hd__decap_3
XFILLER_73_231 VGND VGND VPWR VPWR sky130_fd_sc_hd__decap_3
XFILLER_92_21 VGND VGND VPWR VPWR sky130_fd_sc_hd__decap_3
XTAP_TAPCELL_ROW_57_941 VGND VPWR sky130_fd_sc_hd__tapvpwrvgnd_1
XFILLER_18_169 VGND VGND VPWR VPWR sky130_fd_sc_hd__decap_3
XFILLER_46_489 VGND VGND VPWR VPWR sky130_fd_sc_hd__decap_3
XFILLER_61_426 VGND VGND VPWR VPWR sky130_fd_sc_hd__decap_3
XFILLER_73_275 VGND VGND VPWR VPWR sky130_fd_sc_hd__decap_3
XFILLER_92_32 VGND VGND VPWR VPWR sky130_fd_sc_hd__decap_3
XFILLER_26_180 VGND VGND VPWR VPWR sky130_fd_sc_hd__decap_3
XFILLER_42_640 VGND VGND VPWR VPWR sky130_fd_sc_hd__decap_3
XFILLER_14_342 VGND VGND VPWR VPWR sky130_fd_sc_hd__decap_3
XFILLER_41_150 VGND VGND VPWR VPWR sky130_fd_sc_hd__decap_3
XFILLER_42_651 VGND VGND VPWR VPWR sky130_fd_sc_hd__decap_3
XFILLER_42_684 VGND VGND VPWR VPWR sky130_fd_sc_hd__decap_3
XFILLER_10_581 VGND VGND VPWR VPWR sky130_fd_sc_hd__decap_3
XFILLER_6_552 VGND VGND VPWR VPWR sky130_fd_sc_hd__decap_3
XFILLER_108_480 VGND VGND VPWR VPWR sky130_fd_sc_hd__decap_3
XFILLER_51_6 VGND VGND VPWR VPWR sky130_fd_sc_hd__fill_2
XFILLER_6_585 VGND VGND VPWR VPWR sky130_fd_sc_hd__decap_3
XTAP_TAPCELL_ROW_71_1103 VGND VPWR sky130_fd_sc_hd__tapvpwrvgnd_1
XFILLER_111_612 VGND VGND VPWR VPWR sky130_fd_sc_hd__decap_3
XFILLER_96_312 VGND VGND VPWR VPWR sky130_fd_sc_hd__decap_3
XFILLER_111_623 VGND VGND VPWR VPWR sky130_fd_sc_hd__decap_3
XFILLER_111_656 VGND VGND VPWR VPWR sky130_fd_sc_hd__decap_3
XFILLER_69_559 VGND VGND VPWR VPWR sky130_fd_sc_hd__fill_1
X_5080_ _5080_/A0 _5079_/X _5080_/S VGND VGND VPWR VPWR _7257_/D sky130_fd_sc_hd__mux2_2
X_4100_ _7269_/Q _4408_/A2 _4349_/B1 _7237_/Q _4099_/X VGND VGND VPWR VPWR _4100_/X
+ sky130_fd_sc_hd__a221o_2
XFILLER_2_41 VGND VGND VPWR VPWR sky130_fd_sc_hd__decap_3
XFILLER_96_356 VGND VGND VPWR VPWR sky130_fd_sc_hd__decap_3
XFILLER_110_177 VGND VGND VPWR VPWR sky130_fd_sc_hd__fill_2
XFILLER_2_74 VGND VGND VPWR VPWR sky130_fd_sc_hd__decap_3
XFILLER_2_85 VGND VGND VPWR VPWR sky130_fd_sc_hd__decap_3
XFILLER_37_401 VGND VGND VPWR VPWR sky130_fd_sc_hd__fill_1
XFILLER_37_434 VGND VGND VPWR VPWR sky130_fd_sc_hd__decap_3
XFILLER_49_261 VGND VGND VPWR VPWR sky130_fd_sc_hd__decap_3
XFILLER_64_231 VGND VGND VPWR VPWR sky130_fd_sc_hd__decap_3
XFILLER_64_253 VGND VGND VPWR VPWR sky130_fd_sc_hd__fill_1
XTAP_TAPCELL_ROW_69_1076 VGND VPWR sky130_fd_sc_hd__tapvpwrvgnd_1
XFILLER_24_128 VGND VGND VPWR VPWR sky130_fd_sc_hd__decap_3
XFILLER_64_297 VGND VGND VPWR VPWR sky130_fd_sc_hd__decap_3
X_4933_ _4933_/A0 _4932_/X _5028_/S VGND VGND VPWR VPWR _7266_/D sky130_fd_sc_hd__mux2_2
XTAP_TAPCELL_ROW_82_1232 VGND VPWR sky130_fd_sc_hd__tapvpwrvgnd_1
XFILLER_33_673 VGND VGND VPWR VPWR sky130_fd_sc_hd__decap_3
XTAP_TAPCELL_ROW_35_668 VGND VPWR sky130_fd_sc_hd__tapvpwrvgnd_1
XFILLER_32_161 VGND VGND VPWR VPWR sky130_fd_sc_hd__decap_3
X_4864_ _5092_/C _4857_/X _4860_/Y _7000_/D _4997_/A1 VGND VGND VPWR VPWR _4864_/X
+ sky130_fd_sc_hd__a32o_2
X_6603_ _6632_/A VGND VGND VPWR VPWR _6603_/Y sky130_fd_sc_hd__inv_2
X_4795_ _4795_/A _4795_/B VGND VGND VPWR VPWR _4795_/X sky130_fd_sc_hd__xor2_2
X_3815_ _6928_/Q _3926_/A2 _3925_/A2 _6702_/Q VGND VGND VPWR VPWR _3815_/X sky130_fd_sc_hd__a22o_2
X_6534_ _6568_/A VGND VGND VPWR VPWR _6534_/Y sky130_fd_sc_hd__inv_2
X_3746_ _3746_/A _3746_/B _3746_/C VGND VGND VPWR VPWR _3746_/X sky130_fd_sc_hd__and3_2
XFILLER_106_406 VGND VGND VPWR VPWR sky130_fd_sc_hd__fill_2
X_6465_ _6660_/A VGND VGND VPWR VPWR _6465_/Y sky130_fd_sc_hd__inv_2
XFILLER_106_417 VGND VGND VPWR VPWR sky130_fd_sc_hd__decap_3
X_3677_ _6942_/Q VGND VGND VPWR VPWR _3677_/Y sky130_fd_sc_hd__inv_2
X_6396_ _6651_/A VGND VGND VPWR VPWR _6396_/Y sky130_fd_sc_hd__inv_2
XFILLER_114_472 VGND VGND VPWR VPWR sky130_fd_sc_hd__decap_3
XTAP_TAPCELL_ROW_93_1372 VGND VPWR sky130_fd_sc_hd__tapvpwrvgnd_1
XTAP_TAPCELL_ROW_7_338 VGND VPWR sky130_fd_sc_hd__tapvpwrvgnd_1
XFILLER_99_172 VGND VGND VPWR VPWR sky130_fd_sc_hd__decap_3
XFILLER_101_122 VGND VGND VPWR VPWR sky130_fd_sc_hd__decap_3
XFILLER_102_634 VGND VGND VPWR VPWR sky130_fd_sc_hd__decap_3
XFILLER_102_645 VGND VGND VPWR VPWR sky130_fd_sc_hd__decap_3
X_5278_ _5278_/A0 _5107_/X _5292_/S VGND VGND VPWR VPWR _7191_/D sky130_fd_sc_hd__mux2_2
XFILLER_102_678 VGND VGND VPWR VPWR sky130_fd_sc_hd__decap_3
XFILLER_47_209 VGND VGND VPWR VPWR sky130_fd_sc_hd__decap_3
XFILLER_87_356 VGND VGND VPWR VPWR sky130_fd_sc_hd__fill_1
X_7017_ _7264_/CLK _7017_/D _6297_/Y VGND VGND VPWR VPWR _7017_/Q sky130_fd_sc_hd__dfrtp_2
X_4229_ _7099_/Q _4321_/A2 _3407_/X _7131_/Q VGND VGND VPWR VPWR _4229_/X sky130_fd_sc_hd__a22o_2
XFILLER_68_581 VGND VGND VPWR VPWR sky130_fd_sc_hd__decap_3
XFILLER_75_529 VGND VGND VPWR VPWR sky130_fd_sc_hd__decap_3
XFILLER_55_242 VGND VGND VPWR VPWR sky130_fd_sc_hd__decap_3
XFILLER_83_540 VGND VGND VPWR VPWR sky130_fd_sc_hd__decap_3
XFILLER_15_106 VGND VGND VPWR VPWR sky130_fd_sc_hd__decap_3
XFILLER_16_618 VGND VGND VPWR VPWR sky130_fd_sc_hd__decap_3
XTAP_TAPCELL_ROW_54_900 VGND VPWR sky130_fd_sc_hd__tapvpwrvgnd_1
XFILLER_102_42 VGND VGND VPWR VPWR sky130_fd_sc_hd__decap_3
XFILLER_102_64 VGND VGND VPWR VPWR sky130_fd_sc_hd__decap_3
XFILLER_102_97 VGND VGND VPWR VPWR sky130_fd_sc_hd__decap_3
XFILLER_30_109 VGND VGND VPWR VPWR sky130_fd_sc_hd__fill_2
XFILLER_62_35 VGND VGND VPWR VPWR sky130_fd_sc_hd__decap_3
XFILLER_70_256 VGND VGND VPWR VPWR sky130_fd_sc_hd__decap_3
XFILLER_11_323 VGND VGND VPWR VPWR sky130_fd_sc_hd__decap_3
XFILLER_23_172 VGND VGND VPWR VPWR sky130_fd_sc_hd__decap_3
XFILLER_51_481 VGND VGND VPWR VPWR sky130_fd_sc_hd__decap_3
XFILLER_62_68 VGND VGND VPWR VPWR sky130_fd_sc_hd__decap_3
XFILLER_70_289 VGND VGND VPWR VPWR sky130_fd_sc_hd__fill_1
XFILLER_109_211 VGND VGND VPWR VPWR sky130_fd_sc_hd__decap_3
XFILLER_109_244 VGND VGND VPWR VPWR sky130_fd_sc_hd__decap_3
XFILLER_109_277 VGND VGND VPWR VPWR sky130_fd_sc_hd__decap_3
XFILLER_11_72 VGND VGND VPWR VPWR sky130_fd_sc_hd__fill_1
XFILLER_11_94 VGND VGND VPWR VPWR sky130_fd_sc_hd__decap_3
XFILLER_105_461 VGND VGND VPWR VPWR sky130_fd_sc_hd__fill_1
XFILLER_112_409 VGND VGND VPWR VPWR sky130_fd_sc_hd__decap_3
XFILLER_87_21 VGND VGND VPWR VPWR sky130_fd_sc_hd__decap_3
XFILLER_105_483 VGND VGND VPWR VPWR sky130_fd_sc_hd__decap_3
XFILLER_3_599 VGND VGND VPWR VPWR sky130_fd_sc_hd__fill_2
XFILLER_78_312 VGND VGND VPWR VPWR sky130_fd_sc_hd__decap_3
XFILLER_78_345 VGND VGND VPWR VPWR sky130_fd_sc_hd__decap_3
XFILLER_87_65 VGND VGND VPWR VPWR sky130_fd_sc_hd__decap_3
XFILLER_38_209 VGND VGND VPWR VPWR sky130_fd_sc_hd__decap_3
XFILLER_87_87 VGND VGND VPWR VPWR sky130_fd_sc_hd__decap_3
XFILLER_16_9 VGND VGND VPWR VPWR sky130_fd_sc_hd__decap_3
XFILLER_59_592 VGND VGND VPWR VPWR sky130_fd_sc_hd__decap_3
XFILLER_66_529 VGND VGND VPWR VPWR sky130_fd_sc_hd__decap_3
XFILLER_93_337 VGND VGND VPWR VPWR sky130_fd_sc_hd__decap_3
XFILLER_46_242 VGND VGND VPWR VPWR sky130_fd_sc_hd__decap_3
XFILLER_74_584 VGND VGND VPWR VPWR sky130_fd_sc_hd__decap_3
XTAP_TAPCELL_ROW_105_1508 VGND VPWR sky130_fd_sc_hd__tapvpwrvgnd_1
XFILLER_36_91 VGND VGND VPWR VPWR sky130_fd_sc_hd__fill_1
XFILLER_61_223 VGND VGND VPWR VPWR sky130_fd_sc_hd__fill_1
XFILLER_61_234 VGND VGND VPWR VPWR sky130_fd_sc_hd__decap_3
XFILLER_74_595 VGND VGND VPWR VPWR sky130_fd_sc_hd__decap_3
XFILLER_15_673 VGND VGND VPWR VPWR sky130_fd_sc_hd__fill_2
XFILLER_61_267 VGND VGND VPWR VPWR sky130_fd_sc_hd__decap_3
XTAP_TAPCELL_ROW_32_638 VGND VPWR sky130_fd_sc_hd__tapvpwrvgnd_1
XFILLER_99_6 VGND VGND VPWR VPWR sky130_fd_sc_hd__decap_3
XFILLER_14_194 VGND VGND VPWR VPWR sky130_fd_sc_hd__fill_2
XFILLER_30_665 VGND VGND VPWR VPWR sky130_fd_sc_hd__fill_1
XTAP_TAPCELL_ROW_60_969 VGND VPWR sky130_fd_sc_hd__tapvpwrvgnd_1
X_3600_ _3600_/A VGND VGND VPWR VPWR _3600_/Y sky130_fd_sc_hd__inv_2
XTAP_TAPCELL_ROW_12_395 VGND VPWR sky130_fd_sc_hd__tapvpwrvgnd_1
XFILLER_115_214 VGND VGND VPWR VPWR sky130_fd_sc_hd__decap_3
Xhold806 _6973_/Q VGND VGND VPWR VPWR _6973_/D sky130_fd_sc_hd__dlygate4sd3_1
Xhold817 _6813_/Q VGND VGND VPWR VPWR _6813_/D sky130_fd_sc_hd__dlygate4sd3_1
Xhold828 _6857_/Q VGND VGND VPWR VPWR _6857_/D sky130_fd_sc_hd__dlygate4sd3_1
XTAP_TAPCELL_ROW_116_1648 VGND VPWR sky130_fd_sc_hd__tapvpwrvgnd_1
XFILLER_115_225 VGND VGND VPWR VPWR sky130_fd_sc_hd__decap_3
Xhold839 _6894_/Q VGND VGND VPWR VPWR _6894_/D sky130_fd_sc_hd__dlygate4sd3_1
Xmax_cap569 _6525_/A VGND VGND VPWR VPWR _6617_/A sky130_fd_sc_hd__clkbuf_2
Xmax_cap558 _4186_/Y VGND VGND VPWR VPWR _4950_/A sky130_fd_sc_hd__clkbuf_2
X_3462_ _7249_/Q _4356_/A2 _3459_/X _3461_/X VGND VGND VPWR VPWR _3462_/X sky130_fd_sc_hd__a211o_2
XTAP_TAPCELL_ROW_116_1659 VGND VPWR sky130_fd_sc_hd__tapvpwrvgnd_1
XFILLER_103_409 VGND VGND VPWR VPWR sky130_fd_sc_hd__decap_3
XFILLER_115_269 VGND VGND VPWR VPWR sky130_fd_sc_hd__decap_3
X_5132_ _5132_/A0 _5131_/X _5136_/S VGND VGND VPWR VPWR _7252_/D sky130_fd_sc_hd__mux2_2
XFILLER_69_367 VGND VGND VPWR VPWR sky130_fd_sc_hd__decap_3
XFILLER_84_304 VGND VGND VPWR VPWR sky130_fd_sc_hd__decap_3
XFILLER_97_654 VGND VGND VPWR VPWR sky130_fd_sc_hd__decap_3
XFILLER_97_676 VGND VGND VPWR VPWR sky130_fd_sc_hd__decap_3
XFILLER_111_486 VGND VGND VPWR VPWR sky130_fd_sc_hd__decap_3
XFILLER_96_197 VGND VGND VPWR VPWR sky130_fd_sc_hd__decap_3
X_5063_ _5063_/A0 _5061_/X _5126_/S VGND VGND VPWR VPWR _7258_/D sky130_fd_sc_hd__mux2_2
XFILLER_37_242 VGND VGND VPWR VPWR sky130_fd_sc_hd__decap_3
XFILLER_37_275 VGND VGND VPWR VPWR sky130_fd_sc_hd__decap_3
XFILLER_65_573 VGND VGND VPWR VPWR sky130_fd_sc_hd__fill_2
XFILLER_65_584 VGND VGND VPWR VPWR sky130_fd_sc_hd__decap_3
XFILLER_37_297 VGND VGND VPWR VPWR sky130_fd_sc_hd__decap_3
XFILLER_52_212 VGND VGND VPWR VPWR sky130_fd_sc_hd__decap_3
XFILLER_80_521 VGND VGND VPWR VPWR sky130_fd_sc_hd__decap_3
XFILLER_52_256 VGND VGND VPWR VPWR sky130_fd_sc_hd__decap_3
XFILLER_80_554 VGND VGND VPWR VPWR sky130_fd_sc_hd__decap_3
X_4916_ _4916_/A _4916_/B VGND VGND VPWR VPWR _4967_/A sky130_fd_sc_hd__nand2_2
XFILLER_21_643 VGND VGND VPWR VPWR sky130_fd_sc_hd__decap_3
XFILLER_32_27 VGND VGND VPWR VPWR sky130_fd_sc_hd__fill_1
XFILLER_32_38 VGND VGND VPWR VPWR sky130_fd_sc_hd__decap_3
X_4847_ _4968_/A _4384_/C _4206_/X VGND VGND VPWR VPWR _4904_/B sky130_fd_sc_hd__a21oi_2
XFILLER_20_153 VGND VGND VPWR VPWR sky130_fd_sc_hd__decap_3
XFILLER_20_186 VGND VGND VPWR VPWR sky130_fd_sc_hd__fill_2
XFILLER_20_197 VGND VGND VPWR VPWR sky130_fd_sc_hd__decap_3
X_4778_ _4778_/A _4778_/B VGND VGND VPWR VPWR _4827_/B sky130_fd_sc_hd__and2_2
XFILLER_106_214 VGND VGND VPWR VPWR sky130_fd_sc_hd__decap_3
X_6517_ _6642_/A VGND VGND VPWR VPWR _6517_/Y sky130_fd_sc_hd__inv_2
X_3729_ _6968_/Q _3879_/A2 _3878_/B1 _6962_/Q VGND VGND VPWR VPWR _3729_/X sky130_fd_sc_hd__a22o_2
X_6448_ _6608_/A VGND VGND VPWR VPWR _6448_/Y sky130_fd_sc_hd__inv_2
XFILLER_79_109 VGND VGND VPWR VPWR sky130_fd_sc_hd__decap_3
X_6379_ _6568_/A VGND VGND VPWR VPWR _6379_/Y sky130_fd_sc_hd__inv_2
XFILLER_114_280 VGND VGND VPWR VPWR sky130_fd_sc_hd__decap_3
XFILLER_88_632 VGND VGND VPWR VPWR sky130_fd_sc_hd__fill_2
XFILLER_0_558 VGND VGND VPWR VPWR sky130_fd_sc_hd__fill_2
XFILLER_57_24 VGND VGND VPWR VPWR sky130_fd_sc_hd__decap_3
XFILLER_87_131 VGND VGND VPWR VPWR sky130_fd_sc_hd__decap_3
XFILLER_88_654 VGND VGND VPWR VPWR sky130_fd_sc_hd__decap_3
XFILLER_102_486 VGND VGND VPWR VPWR sky130_fd_sc_hd__decap_3
XFILLER_57_57 VGND VGND VPWR VPWR sky130_fd_sc_hd__decap_3
XFILLER_75_304 VGND VGND VPWR VPWR sky130_fd_sc_hd__decap_3
XFILLER_75_337 VGND VGND VPWR VPWR sky130_fd_sc_hd__decap_3
XFILLER_87_164 VGND VGND VPWR VPWR sky130_fd_sc_hd__decap_3
XFILLER_113_30 VGND VGND VPWR VPWR sky130_fd_sc_hd__decap_3
XFILLER_28_231 VGND VGND VPWR VPWR sky130_fd_sc_hd__fill_1
XFILLER_113_63 VGND VGND VPWR VPWR sky130_fd_sc_hd__decap_3
XFILLER_28_253 VGND VGND VPWR VPWR sky130_fd_sc_hd__decap_3
XFILLER_43_201 VGND VGND VPWR VPWR sky130_fd_sc_hd__decap_3
XFILLER_56_584 VGND VGND VPWR VPWR sky130_fd_sc_hd__decap_3
XFILLER_73_12 VGND VGND VPWR VPWR sky130_fd_sc_hd__decap_3
XFILLER_90_307 VGND VGND VPWR VPWR sky130_fd_sc_hd__fill_1
XFILLER_90_318 VGND VGND VPWR VPWR sky130_fd_sc_hd__fill_1
XFILLER_113_96 VGND VGND VPWR VPWR sky130_fd_sc_hd__decap_3
XFILLER_28_297 VGND VGND VPWR VPWR sky130_fd_sc_hd__decap_3
XFILLER_43_223 VGND VGND VPWR VPWR sky130_fd_sc_hd__fill_1
XFILLER_71_554 VGND VGND VPWR VPWR sky130_fd_sc_hd__fill_2
XFILLER_71_576 VGND VGND VPWR VPWR sky130_fd_sc_hd__decap_3
XFILLER_73_67 VGND VGND VPWR VPWR sky130_fd_sc_hd__decap_3
XTAP_TAPCELL_ROW_100_1449 VGND VPWR sky130_fd_sc_hd__tapvpwrvgnd_1
XFILLER_7_102 VGND VGND VPWR VPWR sky130_fd_sc_hd__decap_3
XFILLER_7_113 VGND VGND VPWR VPWR sky130_fd_sc_hd__decap_3
XFILLER_11_175 VGND VGND VPWR VPWR sky130_fd_sc_hd__decap_3
XFILLER_7_146 VGND VGND VPWR VPWR sky130_fd_sc_hd__decap_3
XFILLER_22_71 VGND VGND VPWR VPWR sky130_fd_sc_hd__decap_3
XFILLER_112_206 VGND VGND VPWR VPWR sky130_fd_sc_hd__decap_3
XFILLER_3_363 VGND VGND VPWR VPWR sky130_fd_sc_hd__decap_3
XFILLER_98_75 VGND VGND VPWR VPWR sky130_fd_sc_hd__fill_1
XFILLER_98_429 VGND VGND VPWR VPWR sky130_fd_sc_hd__decap_3
XFILLER_98_407 VGND VGND VPWR VPWR sky130_fd_sc_hd__decap_3
XFILLER_112_239 VGND VGND VPWR VPWR sky130_fd_sc_hd__fill_1
XFILLER_3_396 VGND VGND VPWR VPWR sky130_fd_sc_hd__decap_3
XFILLER_78_153 VGND VGND VPWR VPWR sky130_fd_sc_hd__decap_3
XFILLER_79_676 VGND VGND VPWR VPWR sky130_fd_sc_hd__decap_3
XTAP_TAPCELL_ROW_111_1578 VGND VPWR sky130_fd_sc_hd__tapvpwrvgnd_1
XFILLER_94_635 VGND VGND VPWR VPWR sky130_fd_sc_hd__decap_3
XTAP_TAPCELL_ROW_111_1589 VGND VPWR sky130_fd_sc_hd__tapvpwrvgnd_1
XFILLER_14_6 VGND VGND VPWR VPWR sky130_fd_sc_hd__decap_3
XFILLER_19_231 VGND VGND VPWR VPWR sky130_fd_sc_hd__decap_3
XFILLER_66_337 VGND VGND VPWR VPWR sky130_fd_sc_hd__decap_3
XFILLER_78_197 VGND VGND VPWR VPWR sky130_fd_sc_hd__decap_3
XFILLER_93_134 VGND VGND VPWR VPWR sky130_fd_sc_hd__fill_1
XFILLER_94_657 VGND VGND VPWR VPWR sky130_fd_sc_hd__decap_3
XFILLER_19_253 VGND VGND VPWR VPWR sky130_fd_sc_hd__decap_3
XFILLER_47_90 VGND VGND VPWR VPWR sky130_fd_sc_hd__decap_3
XFILLER_81_329 VGND VGND VPWR VPWR sky130_fd_sc_hd__decap_3
XFILLER_34_212 VGND VGND VPWR VPWR sky130_fd_sc_hd__decap_3
XFILLER_47_595 VGND VGND VPWR VPWR sky130_fd_sc_hd__fill_2
XFILLER_74_392 VGND VGND VPWR VPWR sky130_fd_sc_hd__fill_1
XFILLER_22_407 VGND VGND VPWR VPWR sky130_fd_sc_hd__decap_3
XFILLER_34_245 VGND VGND VPWR VPWR sky130_fd_sc_hd__decap_3
XFILLER_34_256 VGND VGND VPWR VPWR sky130_fd_sc_hd__decap_3
XTAP_TAPCELL_ROW_66_1046 VGND VPWR sky130_fd_sc_hd__tapvpwrvgnd_1
XTAP_TAPCELL_ROW_17_454 VGND VPWR sky130_fd_sc_hd__tapvpwrvgnd_1
XFILLER_22_418 VGND VGND VPWR VPWR sky130_fd_sc_hd__fill_2
XFILLER_97_3 VGND VGND VPWR VPWR sky130_fd_sc_hd__decap_3
XTAP_TAPCELL_ROW_45_796 VGND VPWR sky130_fd_sc_hd__tapvpwrvgnd_1
X_4701_ _6989_/Q _6990_/Q _5044_/A VGND VGND VPWR VPWR _5026_/A sky130_fd_sc_hd__and3_2
X_4632_ _4626_/X _4274_/Y _4631_/X VGND VGND VPWR VPWR _4916_/B sky130_fd_sc_hd__a21oi_2
XFILLER_8_62 VGND VGND VPWR VPWR sky130_fd_sc_hd__decap_3
XFILLER_116_501 VGND VGND VPWR VPWR sky130_fd_sc_hd__decap_3
X_7351_ clkload5/A _7351_/D _6631_/Y VGND VGND VPWR VPWR _7351_/Q sky130_fd_sc_hd__dfrtp_2
Xhold603 _6749_/Q VGND VGND VPWR VPWR _6749_/D sky130_fd_sc_hd__dlygate4sd3_1
X_4563_ _4563_/A _4567_/B VGND VGND VPWR VPWR _7299_/D sky130_fd_sc_hd__and2_2
XFILLER_116_545 VGND VGND VPWR VPWR sky130_fd_sc_hd__decap_3
XFILLER_7_691 VGND VGND VPWR VPWR sky130_fd_sc_hd__fill_1
X_7282_ _7322_/CLK _7282_/D _6562_/Y VGND VGND VPWR VPWR _7282_/Q sky130_fd_sc_hd__dfrtp_2
Xhold614 _6828_/Q VGND VGND VPWR VPWR _6828_/D sky130_fd_sc_hd__dlygate4sd3_1
Xhold625 _6908_/Q VGND VGND VPWR VPWR _6908_/D sky130_fd_sc_hd__dlygate4sd3_1
Xhold636 _6959_/Q VGND VGND VPWR VPWR _6959_/D sky130_fd_sc_hd__dlygate4sd3_1
X_6302_ _6553_/A VGND VGND VPWR VPWR _6302_/Y sky130_fd_sc_hd__inv_2
XFILLER_116_589 VGND VGND VPWR VPWR sky130_fd_sc_hd__decap_3
Xhold647 _6720_/Q VGND VGND VPWR VPWR _6720_/D sky130_fd_sc_hd__dlygate4sd3_1
Xhold658 _6846_/Q VGND VGND VPWR VPWR _6846_/D sky130_fd_sc_hd__dlygate4sd3_1
Xhold669 _6945_/Q VGND VGND VPWR VPWR _6945_/D sky130_fd_sc_hd__dlygate4sd3_1
XTAP_TAPCELL_ROW_77_1175 VGND VPWR sky130_fd_sc_hd__tapvpwrvgnd_1
XFILLER_103_217 VGND VGND VPWR VPWR sky130_fd_sc_hd__decap_3
XFILLER_103_228 VGND VGND VPWR VPWR sky130_fd_sc_hd__decap_3
XTAP_TAPCELL_ROW_90_1331 VGND VPWR sky130_fd_sc_hd__tapvpwrvgnd_1
X_3376_ _3376_/A _3376_/B VGND VGND VPWR VPWR _3376_/Y sky130_fd_sc_hd__nor2_2
XFILLER_57_315 VGND VGND VPWR VPWR sky130_fd_sc_hd__decap_3
XFILLER_69_164 VGND VGND VPWR VPWR sky130_fd_sc_hd__decap_3
XFILLER_69_175 VGND VGND VPWR VPWR sky130_fd_sc_hd__decap_3
XFILLER_97_473 VGND VGND VPWR VPWR sky130_fd_sc_hd__decap_3
X_5115_ _5101_/A _4292_/C _5113_/Y _5020_/A _5114_/Y VGND VGND VPWR VPWR _5115_/X
+ sky130_fd_sc_hd__o221a_2
XFILLER_27_16 VGND VGND VPWR VPWR sky130_fd_sc_hd__decap_3
XFILLER_57_337 VGND VGND VPWR VPWR sky130_fd_sc_hd__decap_3
XFILLER_85_646 VGND VGND VPWR VPWR sky130_fd_sc_hd__decap_3
X_5046_ _5101_/B VGND VGND VPWR VPWR _5100_/A sky130_fd_sc_hd__inv_2
XFILLER_27_49 VGND VGND VPWR VPWR sky130_fd_sc_hd__decap_3
XFILLER_84_156 VGND VGND VPWR VPWR sky130_fd_sc_hd__fill_1
XFILLER_84_167 VGND VGND VPWR VPWR sky130_fd_sc_hd__decap_3
XFILLER_85_679 VGND VGND VPWR VPWR sky130_fd_sc_hd__decap_3
XFILLER_25_223 VGND VGND VPWR VPWR sky130_fd_sc_hd__fill_1
XFILLER_84_189 VGND VGND VPWR VPWR sky130_fd_sc_hd__decap_3
XFILLER_25_245 VGND VGND VPWR VPWR sky130_fd_sc_hd__fill_2
XFILLER_25_256 VGND VGND VPWR VPWR sky130_fd_sc_hd__decap_3
X_6997_ _7341_/CLK _6997_/D _6277_/Y VGND VGND VPWR VPWR _6997_/Q sky130_fd_sc_hd__dfrtp_2
XFILLER_25_278 VGND VGND VPWR VPWR sky130_fd_sc_hd__fill_2
XFILLER_40_204 VGND VGND VPWR VPWR sky130_fd_sc_hd__decap_3
XFILLER_43_26 VGND VGND VPWR VPWR sky130_fd_sc_hd__fill_1
XFILLER_53_598 VGND VGND VPWR VPWR sky130_fd_sc_hd__decap_3
XFILLER_80_362 VGND VGND VPWR VPWR sky130_fd_sc_hd__fill_2
XFILLER_43_48 VGND VGND VPWR VPWR sky130_fd_sc_hd__decap_3
XFILLER_21_495 VGND VGND VPWR VPWR sky130_fd_sc_hd__decap_3
XFILLER_4_127 VGND VGND VPWR VPWR sky130_fd_sc_hd__decap_3
XFILLER_107_567 VGND VGND VPWR VPWR sky130_fd_sc_hd__decap_3
XFILLER_108_41 VGND VGND VPWR VPWR sky130_fd_sc_hd__decap_3
XFILLER_108_74 VGND VGND VPWR VPWR sky130_fd_sc_hd__decap_3
XFILLER_108_85 VGND VGND VPWR VPWR sky130_fd_sc_hd__decap_3
XFILLER_68_23 VGND VGND VPWR VPWR sky130_fd_sc_hd__decap_3
XFILLER_0_322 VGND VGND VPWR VPWR sky130_fd_sc_hd__fill_2
XFILLER_68_78 VGND VGND VPWR VPWR sky130_fd_sc_hd__decap_3
XFILLER_0_388 VGND VGND VPWR VPWR sky130_fd_sc_hd__decap_3
XFILLER_48_315 VGND VGND VPWR VPWR sky130_fd_sc_hd__fill_2
XFILLER_76_613 VGND VGND VPWR VPWR sky130_fd_sc_hd__decap_3
XFILLER_88_473 VGND VGND VPWR VPWR sky130_fd_sc_hd__decap_3
XFILLER_0_399 VGND VGND VPWR VPWR sky130_fd_sc_hd__decap_3
XFILLER_102_294 VGND VGND VPWR VPWR sky130_fd_sc_hd__decap_3
XFILLER_48_337 VGND VGND VPWR VPWR sky130_fd_sc_hd__decap_3
XFILLER_48_359 VGND VGND VPWR VPWR sky130_fd_sc_hd__decap_3
XFILLER_63_307 VGND VGND VPWR VPWR sky130_fd_sc_hd__decap_3
XFILLER_84_44 VGND VGND VPWR VPWR sky130_fd_sc_hd__decap_3
XFILLER_29_595 VGND VGND VPWR VPWR sky130_fd_sc_hd__decap_3
XFILLER_44_510 VGND VGND VPWR VPWR sky130_fd_sc_hd__fill_2
XFILLER_84_77 VGND VGND VPWR VPWR sky130_fd_sc_hd__decap_3
XFILLER_84_88 VGND VGND VPWR VPWR sky130_fd_sc_hd__fill_1
XFILLER_90_115 VGND VGND VPWR VPWR sky130_fd_sc_hd__decap_3
XFILLER_90_137 VGND VGND VPWR VPWR sky130_fd_sc_hd__decap_3
Xplace318 _4356_/A2 VGND VGND VPWR VPWR _4422_/A2 sky130_fd_sc_hd__buf_2
Xplace307 _3548_/X VGND VGND VPWR VPWR _4948_/A sky130_fd_sc_hd__buf_2
XFILLER_16_256 VGND VGND VPWR VPWR sky130_fd_sc_hd__decap_3
XFILLER_44_554 VGND VGND VPWR VPWR sky130_fd_sc_hd__fill_1
Xplace329 _4289_/B VGND VGND VPWR VPWR _5721_/S sky130_fd_sc_hd__buf_2
XFILLER_16_267 VGND VGND VPWR VPWR sky130_fd_sc_hd__decap_3
XFILLER_71_373 VGND VGND VPWR VPWR sky130_fd_sc_hd__decap_3
XFILLER_31_259 VGND VGND VPWR VPWR sky130_fd_sc_hd__fill_1
XTAP_TAPCELL_ROW_42_755 VGND VPWR sky130_fd_sc_hd__tapvpwrvgnd_1
XTAP_TAPCELL_ROW_14_424 VGND VPWR sky130_fd_sc_hd__tapvpwrvgnd_1
XFILLER_12_473 VGND VGND VPWR VPWR sky130_fd_sc_hd__decap_3
XFILLER_33_70 VGND VGND VPWR VPWR sky130_fd_sc_hd__decap_3
XFILLER_8_411 VGND VGND VPWR VPWR sky130_fd_sc_hd__decap_3
XFILLER_33_81 VGND VGND VPWR VPWR sky130_fd_sc_hd__decap_3
XTAP_TAPCELL_ROW_113_1607 VGND VPWR sky130_fd_sc_hd__tapvpwrvgnd_1
XFILLER_4_672 VGND VGND VPWR VPWR sky130_fd_sc_hd__decap_3
XFILLER_98_248 VGND VGND VPWR VPWR sky130_fd_sc_hd__decap_3
XFILLER_12_3 VGND VGND VPWR VPWR sky130_fd_sc_hd__decap_3
XFILLER_66_123 VGND VGND VPWR VPWR sky130_fd_sc_hd__decap_3
XFILLER_94_421 VGND VGND VPWR VPWR sky130_fd_sc_hd__decap_3
XFILLER_54_307 VGND VGND VPWR VPWR sky130_fd_sc_hd__fill_1
XFILLER_54_318 VGND VGND VPWR VPWR sky130_fd_sc_hd__decap_3
XFILLER_66_178 VGND VGND VPWR VPWR sky130_fd_sc_hd__decap_3
XFILLER_67_679 VGND VGND VPWR VPWR sky130_fd_sc_hd__decap_3
XFILLER_81_104 VGND VGND VPWR VPWR sky130_fd_sc_hd__decap_3
XFILLER_82_616 VGND VGND VPWR VPWR sky130_fd_sc_hd__decap_3
X_6920_ _6975_/CLK _6920_/D VGND VGND VPWR VPWR _6920_/Q sky130_fd_sc_hd__dfxtp_2
X_6851_ _6964_/CLK _6851_/D VGND VGND VPWR VPWR _6851_/Q sky130_fd_sc_hd__dfxtp_2
XFILLER_22_215 VGND VGND VPWR VPWR sky130_fd_sc_hd__decap_3
XFILLER_90_682 VGND VGND VPWR VPWR sky130_fd_sc_hd__decap_3
Xfanout19 _6536_/A VGND VGND VPWR VPWR _6540_/A sky130_fd_sc_hd__buf_2
X_6782_ _7384_/CLK _6782_/D VGND VGND VPWR VPWR _6782_/Q sky130_fd_sc_hd__dfxtp_2
X_3994_ _7345_/Q _3993_/X _3996_/S VGND VGND VPWR VPWR _7345_/D sky130_fd_sc_hd__mux2_2
XFILLER_13_29 VGND VGND VPWR VPWR sky130_fd_sc_hd__decap_3
X_5733_ _7372_/Q hold996/X _5737_/S VGND VGND VPWR VPWR _6716_/D sky130_fd_sc_hd__mux2_2
XFILLER_30_281 VGND VGND VPWR VPWR sky130_fd_sc_hd__decap_3
X_5664_ _5664_/A _5664_/B _5664_/C _5664_/D VGND VGND VPWR VPWR _5665_/D sky130_fd_sc_hd__and4_2
XTAP_TAPCELL_ROW_79_1204 VGND VPWR sky130_fd_sc_hd__tapvpwrvgnd_1
XFILLER_108_309 VGND VGND VPWR VPWR sky130_fd_sc_hd__decap_3
X_7403_ _7403_/CLK _7403_/D _6683_/Y VGND VGND VPWR VPWR _7403_/Q sky130_fd_sc_hd__dfrtp_2
X_5595_ _5595_/A _5595_/B VGND VGND VPWR VPWR _7030_/D sky130_fd_sc_hd__or2_2
X_4615_ _4612_/A _4612_/B _3610_/A VGND VGND VPWR VPWR _4615_/Y sky130_fd_sc_hd__a21oi_2
XFILLER_116_331 VGND VGND VPWR VPWR sky130_fd_sc_hd__decap_3
X_7334_ _7403_/CLK _7334_/D _6614_/Y VGND VGND VPWR VPWR _7334_/Q sky130_fd_sc_hd__dfrtp_2
X_4546_ _7307_/Q _4567_/B VGND VGND VPWR VPWR _7307_/D sky130_fd_sc_hd__and2_2
XFILLER_116_353 VGND VGND VPWR VPWR sky130_fd_sc_hd__decap_3
XFILLER_2_609 VGND VGND VPWR VPWR sky130_fd_sc_hd__decap_3
XFILLER_1_108 VGND VGND VPWR VPWR sky130_fd_sc_hd__decap_3
XFILLER_1_119 VGND VGND VPWR VPWR sky130_fd_sc_hd__decap_3
X_7265_ _7267_/CLK _7265_/D _6545_/Y VGND VGND VPWR VPWR _7265_/Q sky130_fd_sc_hd__dfrtp_2
X_7196_ _7230_/CLK _7196_/D _6476_/Y VGND VGND VPWR VPWR _7196_/Q sky130_fd_sc_hd__dfrtp_2
XFILLER_112_570 VGND VGND VPWR VPWR sky130_fd_sc_hd__fill_1
XFILLER_38_15 VGND VGND VPWR VPWR sky130_fd_sc_hd__decap_3
XFILLER_58_624 VGND VGND VPWR VPWR sky130_fd_sc_hd__decap_3
XFILLER_97_270 VGND VGND VPWR VPWR sky130_fd_sc_hd__decap_3
Xhold1100 _7252_/Q VGND VGND VPWR VPWR _5132_/A0 sky130_fd_sc_hd__dlygate4sd3_1
X_3359_ _5670_/A _5130_/A VGND VGND VPWR VPWR _3376_/A sky130_fd_sc_hd__or2_2
XFILLER_112_592 VGND VGND VPWR VPWR sky130_fd_sc_hd__decap_3
XFILLER_38_37 VGND VGND VPWR VPWR sky130_fd_sc_hd__decap_3
XFILLER_58_657 VGND VGND VPWR VPWR sky130_fd_sc_hd__decap_3
XFILLER_97_281 VGND VGND VPWR VPWR sky130_fd_sc_hd__decap_3
Xhold1111 _7289_/Q VGND VGND VPWR VPWR _4583_/A sky130_fd_sc_hd__dlygate4sd3_1
Xhold1122 _7217_/Q VGND VGND VPWR VPWR _5223_/A sky130_fd_sc_hd__dlygate4sd3_1
Xhold1133 _7162_/Q VGND VGND VPWR VPWR _5338_/A0 sky130_fd_sc_hd__dlygate4sd3_1
XFILLER_57_167 VGND VGND VPWR VPWR sky130_fd_sc_hd__fill_1
Xhold1144 _7140_/Q VGND VGND VPWR VPWR _5386_/A0 sky130_fd_sc_hd__dlygate4sd3_1
Xhold1155 _7340_/Q VGND VGND VPWR VPWR _4478_/A0 sky130_fd_sc_hd__dlygate4sd3_1
Xhold1166 _7037_/Q VGND VGND VPWR VPWR _5583_/A0 sky130_fd_sc_hd__dlygate4sd3_1
XFILLER_57_189 VGND VGND VPWR VPWR sky130_fd_sc_hd__fill_2
XFILLER_66_690 VGND VGND VPWR VPWR sky130_fd_sc_hd__fill_2
XFILLER_73_638 VGND VGND VPWR VPWR sky130_fd_sc_hd__decap_3
Xhold1177 _7156_/Q VGND VGND VPWR VPWR _5350_/A0 sky130_fd_sc_hd__dlygate4sd3_1
Xhold1188 _7175_/Q VGND VGND VPWR VPWR _5310_/A0 sky130_fd_sc_hd__dlygate4sd3_1
Xhold1199 _7337_/Q VGND VGND VPWR VPWR _4484_/A0 sky130_fd_sc_hd__dlygate4sd3_1
XFILLER_38_392 VGND VGND VPWR VPWR sky130_fd_sc_hd__decap_3
XFILLER_53_340 VGND VGND VPWR VPWR sky130_fd_sc_hd__decap_3
XFILLER_54_47 VGND VGND VPWR VPWR sky130_fd_sc_hd__decap_3
XFILLER_53_362 VGND VGND VPWR VPWR sky130_fd_sc_hd__decap_3
XFILLER_81_682 VGND VGND VPWR VPWR sky130_fd_sc_hd__decap_3
XFILLER_110_53 VGND VGND VPWR VPWR sky130_fd_sc_hd__decap_3
XFILLER_13_237 VGND VGND VPWR VPWR sky130_fd_sc_hd__decap_3
XFILLER_80_192 VGND VGND VPWR VPWR sky130_fd_sc_hd__decap_3
XFILLER_70_24 VGND VGND VPWR VPWR sky130_fd_sc_hd__decap_3
XFILLER_70_35 VGND VGND VPWR VPWR sky130_fd_sc_hd__decap_3
XFILLER_9_219 VGND VGND VPWR VPWR sky130_fd_sc_hd__decap_3
XFILLER_21_281 VGND VGND VPWR VPWR sky130_fd_sc_hd__decap_3
XFILLER_70_79 VGND VGND VPWR VPWR sky130_fd_sc_hd__decap_3
XFILLER_107_331 VGND VGND VPWR VPWR sky130_fd_sc_hd__decap_3
XFILLER_5_425 VGND VGND VPWR VPWR sky130_fd_sc_hd__fill_2
XFILLER_5_447 VGND VGND VPWR VPWR sky130_fd_sc_hd__fill_1
XFILLER_79_22 VGND VGND VPWR VPWR sky130_fd_sc_hd__fill_2
XFILLER_79_44 VGND VGND VPWR VPWR sky130_fd_sc_hd__decap_3
XFILLER_107_386 VGND VGND VPWR VPWR sky130_fd_sc_hd__fill_2
XFILLER_1_620 VGND VGND VPWR VPWR sky130_fd_sc_hd__decap_3
XFILLER_79_66 VGND VGND VPWR VPWR sky130_fd_sc_hd__decap_3
XFILLER_1_653 VGND VGND VPWR VPWR sky130_fd_sc_hd__decap_3
XFILLER_0_141 VGND VGND VPWR VPWR sky130_fd_sc_hd__decap_3
XFILLER_49_602 VGND VGND VPWR VPWR sky130_fd_sc_hd__decap_3
XFILLER_95_21 VGND VGND VPWR VPWR sky130_fd_sc_hd__decap_3
XFILLER_49_635 VGND VGND VPWR VPWR sky130_fd_sc_hd__decap_3
XFILLER_76_432 VGND VGND VPWR VPWR sky130_fd_sc_hd__decap_3
XFILLER_48_156 VGND VGND VPWR VPWR sky130_fd_sc_hd__decap_3
XFILLER_49_668 VGND VGND VPWR VPWR sky130_fd_sc_hd__decap_3
XFILLER_49_679 VGND VGND VPWR VPWR sky130_fd_sc_hd__decap_3
XFILLER_64_616 VGND VGND VPWR VPWR sky130_fd_sc_hd__decap_3
XFILLER_95_87 VGND VGND VPWR VPWR sky130_fd_sc_hd__decap_3
XTAP_TAPCELL_ROW_47_814 VGND VPWR sky130_fd_sc_hd__tapvpwrvgnd_1
XFILLER_28_81 VGND VGND VPWR VPWR sky130_fd_sc_hd__decap_3
XFILLER_36_329 VGND VGND VPWR VPWR sky130_fd_sc_hd__decap_3
XFILLER_91_435 VGND VGND VPWR VPWR sky130_fd_sc_hd__decap_3
XFILLER_63_159 VGND VGND VPWR VPWR sky130_fd_sc_hd__decap_3
XFILLER_44_351 VGND VGND VPWR VPWR sky130_fd_sc_hd__decap_3
XTAP_TAPCELL_ROW_63_1005 VGND VPWR sky130_fd_sc_hd__tapvpwrvgnd_1
XTAP_TAPCELL_ROW_27_571 VGND VPWR sky130_fd_sc_hd__tapvpwrvgnd_1
XFILLER_44_80 VGND VGND VPWR VPWR sky130_fd_sc_hd__decap_3
XFILLER_81_6 VGND VGND VPWR VPWR sky130_fd_sc_hd__decap_3
XFILLER_12_292 VGND VGND VPWR VPWR sky130_fd_sc_hd__decap_3
XFILLER_8_263 VGND VGND VPWR VPWR sky130_fd_sc_hd__decap_3
X_4400_ _7178_/Q _4430_/B1 _4428_/B1 _7146_/Q _4399_/X VGND VGND VPWR VPWR _4400_/X
+ sky130_fd_sc_hd__a221o_2
XFILLER_5_30 VGND VGND VPWR VPWR sky130_fd_sc_hd__decap_3
Xoutput527 _6993_/Q VGND VGND VPWR VPWR pc_out[16] sky130_fd_sc_hd__clkdlybuf4s25_1
Xoutput516 _3339_/C1 VGND VGND VPWR VPWR instruction_out[6] sky130_fd_sc_hd__clkdlybuf4s25_1
Xoutput505 _3449_/C VGND VGND VPWR VPWR instruction_out[23] sky130_fd_sc_hd__clkdlybuf4s25_1
XFILLER_5_63 VGND VGND VPWR VPWR sky130_fd_sc_hd__decap_3
Xoutput549 _6984_/Q VGND VGND VPWR VPWR pc_out[7] sky130_fd_sc_hd__clkdlybuf4s25_1
Xoutput538 _7003_/Q VGND VGND VPWR VPWR pc_out[26] sky130_fd_sc_hd__clkdlybuf4s25_1
X_4331_ _7223_/Q _4331_/A2 _4534_/S _7036_/Q VGND VGND VPWR VPWR _4331_/X sky130_fd_sc_hd__a22o_2
XTAP_TAPCELL_ROW_74_1145 VGND VPWR sky130_fd_sc_hd__tapvpwrvgnd_1
XTAP_TAPCELL_ROW_74_1134 VGND VPWR sky130_fd_sc_hd__tapvpwrvgnd_1
XFILLER_99_546 VGND VGND VPWR VPWR sky130_fd_sc_hd__fill_1
XFILLER_4_480 VGND VGND VPWR VPWR sky130_fd_sc_hd__decap_3
XFILLER_5_96 VGND VGND VPWR VPWR sky130_fd_sc_hd__decap_3
X_7050_ _7401_/CLK _7050_/D _6330_/Y VGND VGND VPWR VPWR _7050_/Q sky130_fd_sc_hd__dfrtp_2
X_4262_ _7230_/Q _3377_/X _4532_/S _7294_/Q VGND VGND VPWR VPWR _4262_/X sky130_fd_sc_hd__a22o_2
XFILLER_101_529 VGND VGND VPWR VPWR sky130_fd_sc_hd__decap_3
XFILLER_39_134 VGND VGND VPWR VPWR sky130_fd_sc_hd__decap_3
X_4193_ _7359_/Q _4394_/B _4351_/A2 _7103_/Q VGND VGND VPWR VPWR _4193_/X sky130_fd_sc_hd__a22o_2
XFILLER_27_307 VGND VGND VPWR VPWR sky130_fd_sc_hd__decap_3
XFILLER_94_262 VGND VGND VPWR VPWR sky130_fd_sc_hd__decap_3
XFILLER_39_178 VGND VGND VPWR VPWR sky130_fd_sc_hd__decap_3
XFILLER_55_638 VGND VGND VPWR VPWR sky130_fd_sc_hd__decap_3
XFILLER_67_498 VGND VGND VPWR VPWR sky130_fd_sc_hd__decap_3
XFILLER_82_413 VGND VGND VPWR VPWR sky130_fd_sc_hd__decap_3
XFILLER_35_340 VGND VGND VPWR VPWR sky130_fd_sc_hd__decap_3
XFILLER_70_608 VGND VGND VPWR VPWR sky130_fd_sc_hd__decap_3
XFILLER_82_468 VGND VGND VPWR VPWR sky130_fd_sc_hd__decap_3
X_6903_ _6929_/CLK _6903_/D VGND VGND VPWR VPWR _6903_/Q sky130_fd_sc_hd__dfxtp_2
XFILLER_63_671 VGND VGND VPWR VPWR sky130_fd_sc_hd__fill_1
XFILLER_63_682 VGND VGND VPWR VPWR sky130_fd_sc_hd__fill_2
XTAP_TAPCELL_ROW_85_1274 VGND VPWR sky130_fd_sc_hd__tapvpwrvgnd_1
XFILLER_23_557 VGND VGND VPWR VPWR sky130_fd_sc_hd__decap_3
XFILLER_24_17 VGND VGND VPWR VPWR sky130_fd_sc_hd__decap_3
XFILLER_62_181 VGND VGND VPWR VPWR sky130_fd_sc_hd__decap_3
X_6834_ _6929_/CLK _6834_/D VGND VGND VPWR VPWR _6834_/Q sky130_fd_sc_hd__dfxtp_2
XFILLER_50_354 VGND VGND VPWR VPWR sky130_fd_sc_hd__fill_2
X_6765_ _6964_/CLK _6765_/D VGND VGND VPWR VPWR _6765_/Q sky130_fd_sc_hd__dfxtp_2
X_3977_ _7352_/Q hold971/X _3977_/S VGND VGND VPWR VPWR _7352_/D sky130_fd_sc_hd__mux2_2
XFILLER_109_607 VGND VGND VPWR VPWR sky130_fd_sc_hd__decap_3
XFILLER_109_629 VGND VGND VPWR VPWR sky130_fd_sc_hd__decap_3
X_6696_ _6975_/CLK _6696_/D VGND VGND VPWR VPWR _6696_/Q sky130_fd_sc_hd__dfxtp_2
XFILLER_40_38 VGND VGND VPWR VPWR sky130_fd_sc_hd__fill_1
XFILLER_40_49 VGND VGND VPWR VPWR sky130_fd_sc_hd__decap_3
X_5647_ _5647_/A _5647_/B VGND VGND VPWR VPWR _5647_/Y sky130_fd_sc_hd__nand2_2
XFILLER_116_161 VGND VGND VPWR VPWR sky130_fd_sc_hd__decap_3
XFILLER_116_172 VGND VGND VPWR VPWR sky130_fd_sc_hd__decap_3
XFILLER_2_439 VGND VGND VPWR VPWR sky130_fd_sc_hd__decap_3
X_7317_ clkload5/A _7317_/D _6597_/Y VGND VGND VPWR VPWR _7317_/Q sky130_fd_sc_hd__dfrtp_2
XFILLER_49_25 VGND VGND VPWR VPWR sky130_fd_sc_hd__fill_2
X_7248_ _7356_/CLK _7248_/D _6528_/Y VGND VGND VPWR VPWR _7248_/Q sky130_fd_sc_hd__dfrtp_2
XFILLER_104_389 VGND VGND VPWR VPWR sky130_fd_sc_hd__decap_3
XFILLER_105_42 VGND VGND VPWR VPWR sky130_fd_sc_hd__decap_3
X_7179_ _7372_/CLK _7179_/D _6459_/Y VGND VGND VPWR VPWR _7179_/Q sky130_fd_sc_hd__dfrtp_2
XFILLER_105_64 VGND VGND VPWR VPWR sky130_fd_sc_hd__decap_3
XFILLER_85_240 VGND VGND VPWR VPWR sky130_fd_sc_hd__decap_3
XFILLER_100_573 VGND VGND VPWR VPWR sky130_fd_sc_hd__fill_2
XFILLER_100_595 VGND VGND VPWR VPWR sky130_fd_sc_hd__decap_3
XFILLER_18_318 VGND VGND VPWR VPWR sky130_fd_sc_hd__decap_3
XFILLER_45_126 VGND VGND VPWR VPWR sky130_fd_sc_hd__decap_3
XFILLER_46_627 VGND VGND VPWR VPWR sky130_fd_sc_hd__decap_3
XFILLER_65_35 VGND VGND VPWR VPWR sky130_fd_sc_hd__decap_3
XFILLER_73_424 VGND VGND VPWR VPWR sky130_fd_sc_hd__decap_3
XFILLER_61_608 VGND VGND VPWR VPWR sky130_fd_sc_hd__decap_3
XFILLER_65_68 VGND VGND VPWR VPWR sky130_fd_sc_hd__decap_3
XFILLER_14_502 VGND VGND VPWR VPWR sky130_fd_sc_hd__decap_3
XFILLER_54_660 VGND VGND VPWR VPWR sky130_fd_sc_hd__decap_3
XFILLER_73_479 VGND VGND VPWR VPWR sky130_fd_sc_hd__decap_3
XFILLER_41_332 VGND VGND VPWR VPWR sky130_fd_sc_hd__decap_3
XFILLER_81_12 VGND VGND VPWR VPWR sky130_fd_sc_hd__decap_3
XFILLER_81_490 VGND VGND VPWR VPWR sky130_fd_sc_hd__decap_3
XFILLER_41_343 VGND VGND VPWR VPWR sky130_fd_sc_hd__decap_3
XTAP_TAPCELL_ROW_52_872 VGND VPWR sky130_fd_sc_hd__tapvpwrvgnd_1
XTAP_TAPCELL_ROW_24_541 VGND VPWR sky130_fd_sc_hd__tapvpwrvgnd_1
XFILLER_14_50 VGND VGND VPWR VPWR sky130_fd_sc_hd__decap_3
XFILLER_41_387 VGND VGND VPWR VPWR sky130_fd_sc_hd__decap_3
XFILLER_14_83 VGND VGND VPWR VPWR sky130_fd_sc_hd__fill_1
XFILLER_5_200 VGND VGND VPWR VPWR sky130_fd_sc_hd__decap_3
XFILLER_5_222 VGND VGND VPWR VPWR sky130_fd_sc_hd__fill_2
XFILLER_108_640 VGND VGND VPWR VPWR sky130_fd_sc_hd__decap_3
XFILLER_108_651 VGND VGND VPWR VPWR sky130_fd_sc_hd__decap_3
XFILLER_107_172 VGND VGND VPWR VPWR sky130_fd_sc_hd__decap_3
XFILLER_114_109 VGND VGND VPWR VPWR sky130_fd_sc_hd__decap_3
XFILLER_30_60 VGND VGND VPWR VPWR sky130_fd_sc_hd__decap_3
XFILLER_5_266 VGND VGND VPWR VPWR sky130_fd_sc_hd__decap_3
XFILLER_1_461 VGND VGND VPWR VPWR sky130_fd_sc_hd__decap_3
XFILLER_96_538 VGND VGND VPWR VPWR sky130_fd_sc_hd__decap_3
XFILLER_110_326 VGND VGND VPWR VPWR sky130_fd_sc_hd__fill_2
XFILLER_96_549 VGND VGND VPWR VPWR sky130_fd_sc_hd__decap_3
XFILLER_36_126 VGND VGND VPWR VPWR sky130_fd_sc_hd__decap_3
XFILLER_76_262 VGND VGND VPWR VPWR sky130_fd_sc_hd__decap_3
XFILLER_76_295 VGND VGND VPWR VPWR sky130_fd_sc_hd__decap_3
XFILLER_36_148 VGND VGND VPWR VPWR sky130_fd_sc_hd__decap_3
XFILLER_45_671 VGND VGND VPWR VPWR sky130_fd_sc_hd__fill_1
XFILLER_45_682 VGND VGND VPWR VPWR sky130_fd_sc_hd__decap_3
XFILLER_52_619 VGND VGND VPWR VPWR sky130_fd_sc_hd__decap_3
XFILLER_55_90 VGND VGND VPWR VPWR sky130_fd_sc_hd__decap_3
XFILLER_91_276 VGND VGND VPWR VPWR sky130_fd_sc_hd__decap_3
X_3900_ _3898_/X _3899_/X _5138_/S VGND VGND VPWR VPWR _3900_/Y sky130_fd_sc_hd__o21ai_2
XFILLER_32_365 VGND VGND VPWR VPWR sky130_fd_sc_hd__decap_3
XFILLER_60_663 VGND VGND VPWR VPWR sky130_fd_sc_hd__decap_3
X_3831_ _3682_/A _3828_/X _3830_/X _3714_/X VGND VGND VPWR VPWR _3831_/X sky130_fd_sc_hd__a22o_2
X_6550_ _6584_/A VGND VGND VPWR VPWR _6550_/Y sky130_fd_sc_hd__inv_2
X_3762_ _3746_/C _3759_/X _3760_/X _3833_/S VGND VGND VPWR VPWR _3762_/X sky130_fd_sc_hd__o31a_2
XFILLER_9_561 VGND VGND VPWR VPWR sky130_fd_sc_hd__decap_3
X_6481_ _6611_/A VGND VGND VPWR VPWR _6481_/Y sky130_fd_sc_hd__inv_2
X_3693_ _3693_/A0 _3692_/X _4832_/A VGND VGND VPWR VPWR _7403_/D sky130_fd_sc_hd__mux2_2
XFILLER_114_610 VGND VGND VPWR VPWR sky130_fd_sc_hd__decap_3
XFILLER_113_131 VGND VGND VPWR VPWR sky130_fd_sc_hd__decap_3
XFILLER_114_643 VGND VGND VPWR VPWR sky130_fd_sc_hd__fill_1
XFILLER_114_654 VGND VGND VPWR VPWR sky130_fd_sc_hd__decap_3
X_7102_ _7279_/CLK _7102_/D _6382_/Y VGND VGND VPWR VPWR _7102_/Q sky130_fd_sc_hd__dfrtp_2
X_4314_ _4376_/A _4364_/A _4364_/B _4313_/D VGND VGND VPWR VPWR _4315_/B sky130_fd_sc_hd__o31ai_2
XFILLER_99_354 VGND VGND VPWR VPWR sky130_fd_sc_hd__decap_3
XFILLER_99_332 VGND VGND VPWR VPWR sky130_fd_sc_hd__decap_3
XFILLER_113_164 VGND VGND VPWR VPWR sky130_fd_sc_hd__decap_3
XFILLER_114_687 VGND VGND VPWR VPWR sky130_fd_sc_hd__decap_3
XFILLER_87_505 VGND VGND VPWR VPWR sky130_fd_sc_hd__decap_3
X_5294_ _5294_/A _5294_/B VGND VGND VPWR VPWR _7412_/A sky130_fd_sc_hd__nor2_2
XFILLER_99_387 VGND VGND VPWR VPWR sky130_fd_sc_hd__decap_3
XFILLER_101_326 VGND VGND VPWR VPWR sky130_fd_sc_hd__decap_3
XFILLER_113_175 VGND VGND VPWR VPWR sky130_fd_sc_hd__decap_3
XFILLER_19_17 VGND VGND VPWR VPWR sky130_fd_sc_hd__decap_3
XFILLER_87_538 VGND VGND VPWR VPWR sky130_fd_sc_hd__decap_3
XFILLER_87_549 VGND VGND VPWR VPWR sky130_fd_sc_hd__fill_1
X_7033_ clkload4/A _7033_/D _6313_/Y VGND VGND VPWR VPWR _7033_/Q sky130_fd_sc_hd__dfrtp_2
X_4245_ _7357_/Q _4346_/B1 _3366_/X _7165_/Q _4244_/X VGND VGND VPWR VPWR _4248_/B
+ sky130_fd_sc_hd__a221o_2
XFILLER_28_616 VGND VGND VPWR VPWR sky130_fd_sc_hd__decap_3
X_4176_ _7168_/Q _3366_/X _5229_/C _7136_/Q VGND VGND VPWR VPWR _4176_/X sky130_fd_sc_hd__a22o_2
XFILLER_28_638 VGND VGND VPWR VPWR sky130_fd_sc_hd__decap_3
XFILLER_55_424 VGND VGND VPWR VPWR sky130_fd_sc_hd__fill_2
XFILLER_67_284 VGND VGND VPWR VPWR sky130_fd_sc_hd__decap_3
XFILLER_95_593 VGND VGND VPWR VPWR sky130_fd_sc_hd__decap_3
XFILLER_27_159 VGND VGND VPWR VPWR sky130_fd_sc_hd__decap_3
XFILLER_82_265 VGND VGND VPWR VPWR sky130_fd_sc_hd__decap_3
XFILLER_35_181 VGND VGND VPWR VPWR sky130_fd_sc_hd__decap_3
XFILLER_51_641 VGND VGND VPWR VPWR sky130_fd_sc_hd__decap_3
XFILLER_11_505 VGND VGND VPWR VPWR sky130_fd_sc_hd__fill_1
XFILLER_23_365 VGND VGND VPWR VPWR sky130_fd_sc_hd__decap_3
X_6817_ _6972_/CLK _6817_/D VGND VGND VPWR VPWR _6817_/Q sky130_fd_sc_hd__dfxtp_2
XFILLER_11_549 VGND VGND VPWR VPWR sky130_fd_sc_hd__fill_1
XFILLER_50_162 VGND VGND VPWR VPWR sky130_fd_sc_hd__decap_3
XFILLER_51_685 VGND VGND VPWR VPWR sky130_fd_sc_hd__decap_3
XTAP_TAPCELL_ROW_21_500 VGND VPWR sky130_fd_sc_hd__tapvpwrvgnd_1
XFILLER_50_195 VGND VGND VPWR VPWR sky130_fd_sc_hd__fill_1
XFILLER_51_48 VGND VGND VPWR VPWR sky130_fd_sc_hd__decap_3
X_6748_ _6977_/CLK _6748_/D VGND VGND VPWR VPWR _6748_/Q sky130_fd_sc_hd__dfxtp_2
X_6679_ _6682_/A VGND VGND VPWR VPWR _6679_/Y sky130_fd_sc_hd__inv_2
XTAP_TAPCELL_ROW_98_1432 VGND VPWR sky130_fd_sc_hd__tapvpwrvgnd_1
XFILLER_105_610 VGND VGND VPWR VPWR sky130_fd_sc_hd__decap_3
XFILLER_2_203 VGND VGND VPWR VPWR sky130_fd_sc_hd__decap_3
XFILLER_104_131 VGND VGND VPWR VPWR sky130_fd_sc_hd__decap_3
XFILLER_105_643 VGND VGND VPWR VPWR sky130_fd_sc_hd__decap_3
XFILLER_2_225 VGND VGND VPWR VPWR sky130_fd_sc_hd__decap_3
XFILLER_105_676 VGND VGND VPWR VPWR sky130_fd_sc_hd__decap_3
XFILLER_116_41 VGND VGND VPWR VPWR sky130_fd_sc_hd__decap_3
XFILLER_78_516 VGND VGND VPWR VPWR sky130_fd_sc_hd__decap_3
XFILLER_104_197 VGND VGND VPWR VPWR sky130_fd_sc_hd__decap_3
XFILLER_116_74 VGND VGND VPWR VPWR sky130_fd_sc_hd__decap_3
XFILLER_116_85 VGND VGND VPWR VPWR sky130_fd_sc_hd__fill_1
XFILLER_76_67 VGND VGND VPWR VPWR sky130_fd_sc_hd__decap_3
XFILLER_93_508 VGND VGND VPWR VPWR sky130_fd_sc_hd__fill_2
XFILLER_58_262 VGND VGND VPWR VPWR sky130_fd_sc_hd__decap_3
XFILLER_58_284 VGND VGND VPWR VPWR sky130_fd_sc_hd__decap_3
XFILLER_73_210 VGND VGND VPWR VPWR sky130_fd_sc_hd__decap_3
XTAP_TAPCELL_ROW_29_600 VGND VPWR sky130_fd_sc_hd__tapvpwrvgnd_1
XFILLER_100_381 VGND VGND VPWR VPWR sky130_fd_sc_hd__decap_3
XFILLER_73_243 VGND VGND VPWR VPWR sky130_fd_sc_hd__decap_3
XTAP_TAPCELL_ROW_57_931 VGND VPWR sky130_fd_sc_hd__tapvpwrvgnd_1
XFILLER_61_405 VGND VGND VPWR VPWR sky130_fd_sc_hd__decap_3
XFILLER_73_287 VGND VGND VPWR VPWR sky130_fd_sc_hd__fill_2
XFILLER_92_44 VGND VGND VPWR VPWR sky130_fd_sc_hd__decap_3
XFILLER_14_321 VGND VGND VPWR VPWR sky130_fd_sc_hd__decap_3
XFILLER_61_449 VGND VGND VPWR VPWR sky130_fd_sc_hd__decap_3
XFILLER_92_66 VGND VGND VPWR VPWR sky130_fd_sc_hd__decap_3
XFILLER_92_88 VGND VGND VPWR VPWR sky130_fd_sc_hd__decap_3
XFILLER_14_354 VGND VGND VPWR VPWR sky130_fd_sc_hd__decap_3
XFILLER_14_365 VGND VGND VPWR VPWR sky130_fd_sc_hd__fill_1
XFILLER_25_60 VGND VGND VPWR VPWR sky130_fd_sc_hd__fill_1
XFILLER_25_71 VGND VGND VPWR VPWR sky130_fd_sc_hd__decap_3
XFILLER_26_192 VGND VGND VPWR VPWR sky130_fd_sc_hd__decap_3
XFILLER_42_663 VGND VGND VPWR VPWR sky130_fd_sc_hd__decap_3
XFILLER_25_93 VGND VGND VPWR VPWR sky130_fd_sc_hd__decap_3
XFILLER_41_195 VGND VGND VPWR VPWR sky130_fd_sc_hd__decap_3
XFILLER_108_492 VGND VGND VPWR VPWR sky130_fd_sc_hd__fill_2
XFILLER_44_6 VGND VGND VPWR VPWR sky130_fd_sc_hd__decap_3
XFILLER_6_597 VGND VGND VPWR VPWR sky130_fd_sc_hd__decap_3
XFILLER_69_505 VGND VGND VPWR VPWR sky130_fd_sc_hd__decap_3
XFILLER_96_302 VGND VGND VPWR VPWR sky130_fd_sc_hd__fill_2
XTAP_TAPCELL_ROW_71_1104 VGND VPWR sky130_fd_sc_hd__tapvpwrvgnd_1
XFILLER_111_635 VGND VGND VPWR VPWR sky130_fd_sc_hd__decap_3
XFILLER_69_538 VGND VGND VPWR VPWR sky130_fd_sc_hd__decap_3
XFILLER_96_335 VGND VGND VPWR VPWR sky130_fd_sc_hd__decap_3
XFILLER_111_668 VGND VGND VPWR VPWR sky130_fd_sc_hd__decap_3
XFILLER_111_679 VGND VGND VPWR VPWR sky130_fd_sc_hd__decap_3
XFILLER_2_20 VGND VGND VPWR VPWR sky130_fd_sc_hd__decap_3
XFILLER_2_53 VGND VGND VPWR VPWR sky130_fd_sc_hd__decap_3
XFILLER_49_240 VGND VGND VPWR VPWR sky130_fd_sc_hd__decap_3
XFILLER_96_368 VGND VGND VPWR VPWR sky130_fd_sc_hd__decap_3
XPHY_EDGE_ROW_10_Right_10 VGND VGND VPWR VPWR sky130_fd_sc_hd__decap_3
XFILLER_37_424 VGND VGND VPWR VPWR sky130_fd_sc_hd__decap_3
XFILLER_49_273 VGND VGND VPWR VPWR sky130_fd_sc_hd__decap_3
XFILLER_64_210 VGND VGND VPWR VPWR sky130_fd_sc_hd__decap_3
XFILLER_2_97 VGND VGND VPWR VPWR sky130_fd_sc_hd__decap_3
XFILLER_92_552 VGND VGND VPWR VPWR sky130_fd_sc_hd__decap_3
XFILLER_52_405 VGND VGND VPWR VPWR sky130_fd_sc_hd__decap_3
XFILLER_92_585 VGND VGND VPWR VPWR sky130_fd_sc_hd__decap_3
XTAP_TAPCELL_ROW_69_1077 VGND VPWR sky130_fd_sc_hd__tapvpwrvgnd_1
XFILLER_17_181 VGND VGND VPWR VPWR sky130_fd_sc_hd__decap_3
XFILLER_52_427 VGND VGND VPWR VPWR sky130_fd_sc_hd__decap_3
X_4932_ _5092_/C _4927_/X _4929_/Y _6996_/D _4997_/A1 VGND VGND VPWR VPWR _4932_/X
+ sky130_fd_sc_hd__a32o_2
XTAP_TAPCELL_ROW_82_1233 VGND VPWR sky130_fd_sc_hd__tapvpwrvgnd_1
XTAP_TAPCELL_ROW_35_669 VGND VPWR sky130_fd_sc_hd__tapvpwrvgnd_1
XFILLER_32_173 VGND VGND VPWR VPWR sky130_fd_sc_hd__decap_3
XFILLER_60_471 VGND VGND VPWR VPWR sky130_fd_sc_hd__decap_3
X_6602_ _6664_/A VGND VGND VPWR VPWR _6602_/Y sky130_fd_sc_hd__inv_2
X_3814_ _7391_/Q _3909_/A2 _3813_/Y VGND VGND VPWR VPWR _7391_/D sky130_fd_sc_hd__a21bo_2
XFILLER_21_18 VGND VGND VPWR VPWR sky130_fd_sc_hd__decap_3
X_6533_ _6568_/A VGND VGND VPWR VPWR _6533_/Y sky130_fd_sc_hd__inv_2
X_3745_ _6978_/Q _3891_/A2 _3878_/B1 _6723_/Q _3744_/X VGND VGND VPWR VPWR _3745_/X
+ sky130_fd_sc_hd__a221o_2
X_6464_ _6672_/A VGND VGND VPWR VPWR _6464_/Y sky130_fd_sc_hd__inv_2
X_5415_ _7126_/Q _5121_/X _5429_/S VGND VGND VPWR VPWR _7126_/D sky130_fd_sc_hd__mux2_2
X_3676_ _6716_/Q VGND VGND VPWR VPWR _3676_/Y sky130_fd_sc_hd__inv_2
X_6395_ _6395_/A VGND VGND VPWR VPWR _6395_/Y sky130_fd_sc_hd__inv_2
XFILLER_102_613 VGND VGND VPWR VPWR sky130_fd_sc_hd__decap_3
XFILLER_114_440 VGND VGND VPWR VPWR sky130_fd_sc_hd__decap_3
X_5346_ _7158_/Q _5121_/X _5350_/S VGND VGND VPWR VPWR _7158_/D sky130_fd_sc_hd__mux2_2
XTAP_TAPCELL_ROW_93_1373 VGND VPWR sky130_fd_sc_hd__tapvpwrvgnd_1
XTAP_TAPCELL_ROW_93_1362 VGND VPWR sky130_fd_sc_hd__tapvpwrvgnd_1
XTAP_TAPCELL_ROW_7_339 VGND VPWR sky130_fd_sc_hd__tapvpwrvgnd_1
XFILLER_99_140 VGND VGND VPWR VPWR sky130_fd_sc_hd__decap_3
XFILLER_101_101 VGND VGND VPWR VPWR sky130_fd_sc_hd__decap_3
XFILLER_114_495 VGND VGND VPWR VPWR sky130_fd_sc_hd__decap_3
XFILLER_87_335 VGND VGND VPWR VPWR sky130_fd_sc_hd__fill_1
XFILLER_102_657 VGND VGND VPWR VPWR sky130_fd_sc_hd__decap_3
XFILLER_87_368 VGND VGND VPWR VPWR sky130_fd_sc_hd__decap_3
X_7016_ _7279_/CLK _7016_/D _6296_/Y VGND VGND VPWR VPWR _7016_/Q sky130_fd_sc_hd__dfrtp_2
X_4228_ _7014_/Q _4601_/S _4268_/A2 _7195_/Q _4227_/X VGND VGND VPWR VPWR _4228_/X
+ sky130_fd_sc_hd__a221o_2
XFILLER_101_167 VGND VGND VPWR VPWR sky130_fd_sc_hd__fill_1
XFILLER_46_15 VGND VGND VPWR VPWR sky130_fd_sc_hd__decap_3
XFILLER_110_690 VGND VGND VPWR VPWR sky130_fd_sc_hd__fill_2
XFILLER_46_37 VGND VGND VPWR VPWR sky130_fd_sc_hd__decap_3
XFILLER_46_59 VGND VGND VPWR VPWR sky130_fd_sc_hd__decap_3
XFILLER_55_210 VGND VGND VPWR VPWR sky130_fd_sc_hd__decap_3
X_4159_ _7329_/Q _4159_/A2 _4196_/A2 _7361_/Q _4419_/C1 VGND VGND VPWR VPWR _4159_/X
+ sky130_fd_sc_hd__a221o_2
XPHY_EDGE_ROW_106_Right_106 VGND VGND VPWR VPWR sky130_fd_sc_hd__decap_3
XFILLER_55_254 VGND VGND VPWR VPWR sky130_fd_sc_hd__decap_3
XFILLER_55_276 VGND VGND VPWR VPWR sky130_fd_sc_hd__decap_3
XTAP_TAPCELL_ROW_54_901 VGND VPWR sky130_fd_sc_hd__tapvpwrvgnd_1
XFILLER_43_449 VGND VGND VPWR VPWR sky130_fd_sc_hd__decap_3
XFILLER_55_287 VGND VGND VPWR VPWR sky130_fd_sc_hd__decap_3
XFILLER_102_76 VGND VGND VPWR VPWR sky130_fd_sc_hd__decap_3
XFILLER_24_641 VGND VGND VPWR VPWR sky130_fd_sc_hd__decap_3
XFILLER_70_246 VGND VGND VPWR VPWR sky130_fd_sc_hd__decap_3
XFILLER_70_268 VGND VGND VPWR VPWR sky130_fd_sc_hd__decap_3
Xclkbuf_leaf_35_clk clkload0/A VGND VGND VPWR VPWR _7384_/CLK sky130_fd_sc_hd__clkbuf_16
XFILLER_11_302 VGND VGND VPWR VPWR sky130_fd_sc_hd__decap_3
XFILLER_23_151 VGND VGND VPWR VPWR sky130_fd_sc_hd__decap_3
XFILLER_62_47 VGND VGND VPWR VPWR sky130_fd_sc_hd__decap_3
XFILLER_11_335 VGND VGND VPWR VPWR sky130_fd_sc_hd__fill_1
XFILLER_23_184 VGND VGND VPWR VPWR sky130_fd_sc_hd__decap_3
XFILLER_51_493 VGND VGND VPWR VPWR sky130_fd_sc_hd__decap_3
XTAP_TAPCELL_ROW_102_1480 VGND VPWR sky130_fd_sc_hd__tapvpwrvgnd_1
XFILLER_109_223 VGND VGND VPWR VPWR sky130_fd_sc_hd__fill_1
XFILLER_11_51 VGND VGND VPWR VPWR sky130_fd_sc_hd__decap_3
XFILLER_3_501 VGND VGND VPWR VPWR sky130_fd_sc_hd__decap_3
XFILLER_87_33 VGND VGND VPWR VPWR sky130_fd_sc_hd__decap_3
XFILLER_78_324 VGND VGND VPWR VPWR sky130_fd_sc_hd__decap_3
XFILLER_87_55 VGND VGND VPWR VPWR sky130_fd_sc_hd__fill_1
XFILLER_87_99 VGND VGND VPWR VPWR sky130_fd_sc_hd__decap_3
XFILLER_19_402 VGND VGND VPWR VPWR sky130_fd_sc_hd__decap_3
XFILLER_19_457 VGND VGND VPWR VPWR sky130_fd_sc_hd__decap_3
XFILLER_93_349 VGND VGND VPWR VPWR sky130_fd_sc_hd__decap_3
XFILLER_46_276 VGND VGND VPWR VPWR sky130_fd_sc_hd__decap_3
XFILLER_61_202 VGND VGND VPWR VPWR sky130_fd_sc_hd__decap_3
XFILLER_74_552 VGND VGND VPWR VPWR sky130_fd_sc_hd__decap_3
XTAP_TAPCELL_ROW_105_1509 VGND VPWR sky130_fd_sc_hd__tapvpwrvgnd_1
XFILLER_34_427 VGND VGND VPWR VPWR sky130_fd_sc_hd__fill_1
XFILLER_34_449 VGND VGND VPWR VPWR sky130_fd_sc_hd__decap_3
XFILLER_36_70 VGND VGND VPWR VPWR sky130_fd_sc_hd__decap_3
XFILLER_61_246 VGND VGND VPWR VPWR sky130_fd_sc_hd__decap_3
Xclkbuf_leaf_26_clk clkload1/A VGND VGND VPWR VPWR _6966_/CLK sky130_fd_sc_hd__clkbuf_16
XFILLER_14_173 VGND VGND VPWR VPWR sky130_fd_sc_hd__decap_3
XFILLER_61_279 VGND VGND VPWR VPWR sky130_fd_sc_hd__fill_1
XTAP_TAPCELL_ROW_32_639 VGND VPWR sky130_fd_sc_hd__tapvpwrvgnd_1
XFILLER_52_91 VGND VGND VPWR VPWR sky130_fd_sc_hd__decap_3
XTAP_TAPCELL_ROW_12_396 VGND VPWR sky130_fd_sc_hd__tapvpwrvgnd_1
XFILLER_6_361 VGND VGND VPWR VPWR sky130_fd_sc_hd__decap_3
Xhold807 _6741_/Q VGND VGND VPWR VPWR _6741_/D sky130_fd_sc_hd__dlygate4sd3_1
Xhold818 _6849_/Q VGND VGND VPWR VPWR _6849_/D sky130_fd_sc_hd__dlygate4sd3_1
XTAP_TAPCELL_ROW_116_1649 VGND VPWR sky130_fd_sc_hd__tapvpwrvgnd_1
XTAP_TAPCELL_ROW_116_1638 VGND VPWR sky130_fd_sc_hd__tapvpwrvgnd_1
XFILLER_115_237 VGND VGND VPWR VPWR sky130_fd_sc_hd__decap_3
Xhold829 _6882_/Q VGND VGND VPWR VPWR _6882_/D sky130_fd_sc_hd__dlygate4sd3_1
Xmax_cap559 _4987_/A VGND VGND VPWR VPWR _4620_/C sky130_fd_sc_hd__clkbuf_2
X_3461_ _7281_/Q _4532_/S _4339_/B1 _7153_/Q _3460_/X VGND VGND VPWR VPWR _3461_/X
+ sky130_fd_sc_hd__a221o_2
XFILLER_42_3 VGND VGND VPWR VPWR sky130_fd_sc_hd__decap_3
X_5200_ _5200_/A _5217_/B VGND VGND VPWR VPWR _7228_/D sky130_fd_sc_hd__and2_2
X_3392_ _3429_/A _3429_/B VGND VGND VPWR VPWR _3591_/A sky130_fd_sc_hd__nor2_2
XFILLER_96_110 VGND VGND VPWR VPWR sky130_fd_sc_hd__decap_3
X_5131_ _3992_/Y _5128_/Y wire567/X _5156_/S VGND VGND VPWR VPWR _5131_/X sky130_fd_sc_hd__o22a_2
XFILLER_57_508 VGND VGND VPWR VPWR sky130_fd_sc_hd__decap_3
XFILLER_69_346 VGND VGND VPWR VPWR sky130_fd_sc_hd__decap_3
XFILLER_97_666 VGND VGND VPWR VPWR sky130_fd_sc_hd__decap_3
XFILLER_111_498 VGND VGND VPWR VPWR sky130_fd_sc_hd__decap_3
XFILLER_84_316 VGND VGND VPWR VPWR sky130_fd_sc_hd__decap_3
XFILLER_97_688 VGND VGND VPWR VPWR sky130_fd_sc_hd__decap_3
XFILLER_37_221 VGND VGND VPWR VPWR sky130_fd_sc_hd__decap_3
XFILLER_92_360 VGND VGND VPWR VPWR sky130_fd_sc_hd__decap_3
XFILLER_16_18 VGND VGND VPWR VPWR sky130_fd_sc_hd__decap_3
XFILLER_16_29 VGND VGND VPWR VPWR sky130_fd_sc_hd__decap_3
XFILLER_25_449 VGND VGND VPWR VPWR sky130_fd_sc_hd__fill_2
XFILLER_52_224 VGND VGND VPWR VPWR sky130_fd_sc_hd__decap_3
XFILLER_80_533 VGND VGND VPWR VPWR sky130_fd_sc_hd__decap_3
XFILLER_92_371 VGND VGND VPWR VPWR sky130_fd_sc_hd__fill_1
XFILLER_92_393 VGND VGND VPWR VPWR sky130_fd_sc_hd__decap_3
XFILLER_52_268 VGND VGND VPWR VPWR sky130_fd_sc_hd__decap_3
XFILLER_80_566 VGND VGND VPWR VPWR sky130_fd_sc_hd__decap_3
Xclkbuf_leaf_17_clk clkbuf_3_6__f_clk/X VGND VGND VPWR VPWR _7341_/CLK sky130_fd_sc_hd__clkbuf_16
XFILLER_21_600 VGND VGND VPWR VPWR sky130_fd_sc_hd__fill_2
XFILLER_21_611 VGND VGND VPWR VPWR sky130_fd_sc_hd__decap_3
XFILLER_20_121 VGND VGND VPWR VPWR sky130_fd_sc_hd__decap_3
XFILLER_60_290 VGND VGND VPWR VPWR sky130_fd_sc_hd__decap_3
X_4846_ _4903_/A _4890_/B VGND VGND VPWR VPWR _4884_/A sky130_fd_sc_hd__nand2_2
XFILLER_20_165 VGND VGND VPWR VPWR sky130_fd_sc_hd__decap_3
X_6516_ _6610_/A VGND VGND VPWR VPWR _6516_/Y sky130_fd_sc_hd__inv_2
X_4777_ _4777_/A _4777_/B _4777_/C VGND VGND VPWR VPWR _4777_/X sky130_fd_sc_hd__and3_2
XFILLER_113_9 VGND VGND VPWR VPWR sky130_fd_sc_hd__decap_3
XFILLER_4_309 VGND VGND VPWR VPWR sky130_fd_sc_hd__fill_2
X_3728_ _3746_/A _3728_/B VGND VGND VPWR VPWR _3728_/Y sky130_fd_sc_hd__nor2_2
XFILLER_106_226 VGND VGND VPWR VPWR sky130_fd_sc_hd__decap_3
X_6447_ _6610_/A VGND VGND VPWR VPWR _6447_/Y sky130_fd_sc_hd__inv_2
X_6378_ _6539_/A VGND VGND VPWR VPWR _6378_/Y sky130_fd_sc_hd__inv_2
XFILLER_102_421 VGND VGND VPWR VPWR sky130_fd_sc_hd__decap_3
X_5329_ _7166_/Q _4997_/X _5350_/S VGND VGND VPWR VPWR _7166_/D sky130_fd_sc_hd__mux2_2
XFILLER_48_508 VGND VGND VPWR VPWR sky130_fd_sc_hd__decap_3
XFILLER_87_143 VGND VGND VPWR VPWR sky130_fd_sc_hd__decap_3
XFILLER_88_666 VGND VGND VPWR VPWR sky130_fd_sc_hd__decap_3
XFILLER_102_465 VGND VGND VPWR VPWR sky130_fd_sc_hd__decap_3
XFILLER_57_36 VGND VGND VPWR VPWR sky130_fd_sc_hd__decap_3
XFILLER_57_69 VGND VGND VPWR VPWR sky130_fd_sc_hd__decap_3
XFILLER_56_530 VGND VGND VPWR VPWR sky130_fd_sc_hd__fill_2
XFILLER_56_541 VGND VGND VPWR VPWR sky130_fd_sc_hd__decap_3
XFILLER_113_42 VGND VGND VPWR VPWR sky130_fd_sc_hd__decap_3
XFILLER_28_243 VGND VGND VPWR VPWR sky130_fd_sc_hd__decap_3
XFILLER_28_265 VGND VGND VPWR VPWR sky130_fd_sc_hd__decap_3
XFILLER_113_75 VGND VGND VPWR VPWR sky130_fd_sc_hd__decap_3
XFILLER_71_511 VGND VGND VPWR VPWR sky130_fd_sc_hd__fill_1
XFILLER_73_24 VGND VGND VPWR VPWR sky130_fd_sc_hd__decap_3
XFILLER_83_371 VGND VGND VPWR VPWR sky130_fd_sc_hd__decap_3
XFILLER_83_393 VGND VGND VPWR VPWR sky130_fd_sc_hd__decap_3
XFILLER_43_235 VGND VGND VPWR VPWR sky130_fd_sc_hd__decap_3
XFILLER_43_257 VGND VGND VPWR VPWR sky130_fd_sc_hd__fill_2
XFILLER_73_57 VGND VGND VPWR VPWR sky130_fd_sc_hd__fill_1
XFILLER_71_588 VGND VGND VPWR VPWR sky130_fd_sc_hd__decap_3
XFILLER_12_633 VGND VGND VPWR VPWR sky130_fd_sc_hd__fill_2
XFILLER_51_290 VGND VGND VPWR VPWR sky130_fd_sc_hd__decap_3
XFILLER_7_125 VGND VGND VPWR VPWR sky130_fd_sc_hd__decap_3
XFILLER_22_83 VGND VGND VPWR VPWR sky130_fd_sc_hd__fill_1
XFILLER_22_94 VGND VGND VPWR VPWR sky130_fd_sc_hd__decap_3
XFILLER_7_158 VGND VGND VPWR VPWR sky130_fd_sc_hd__decap_3
XFILLER_7_169 VGND VGND VPWR VPWR sky130_fd_sc_hd__decap_3
XFILLER_98_32 VGND VGND VPWR VPWR sky130_fd_sc_hd__decap_3
XFILLER_98_54 VGND VGND VPWR VPWR sky130_fd_sc_hd__decap_3
XFILLER_98_419 VGND VGND VPWR VPWR sky130_fd_sc_hd__fill_1
XFILLER_112_218 VGND VGND VPWR VPWR sky130_fd_sc_hd__decap_3
XFILLER_3_375 VGND VGND VPWR VPWR sky130_fd_sc_hd__decap_3
XFILLER_79_611 VGND VGND VPWR VPWR sky130_fd_sc_hd__decap_3
XFILLER_105_292 VGND VGND VPWR VPWR sky130_fd_sc_hd__decap_3
XFILLER_78_132 VGND VGND VPWR VPWR sky130_fd_sc_hd__decap_3
XFILLER_79_644 VGND VGND VPWR VPWR sky130_fd_sc_hd__decap_3
XTAP_TAPCELL_ROW_111_1579 VGND VPWR sky130_fd_sc_hd__tapvpwrvgnd_1
XFILLER_66_305 VGND VGND VPWR VPWR sky130_fd_sc_hd__decap_3
XFILLER_79_688 VGND VGND VPWR VPWR sky130_fd_sc_hd__decap_3
XFILLER_93_113 VGND VGND VPWR VPWR sky130_fd_sc_hd__decap_3
XFILLER_59_390 VGND VGND VPWR VPWR sky130_fd_sc_hd__fill_2
XFILLER_94_669 VGND VGND VPWR VPWR sky130_fd_sc_hd__decap_3
XFILLER_19_265 VGND VGND VPWR VPWR sky130_fd_sc_hd__decap_3
XFILLER_19_287 VGND VGND VPWR VPWR sky130_fd_sc_hd__decap_3
XFILLER_19_298 VGND VGND VPWR VPWR sky130_fd_sc_hd__decap_3
XFILLER_34_224 VGND VGND VPWR VPWR sky130_fd_sc_hd__decap_3
XFILLER_62_511 VGND VGND VPWR VPWR sky130_fd_sc_hd__fill_1
XFILLER_62_533 VGND VGND VPWR VPWR sky130_fd_sc_hd__decap_3
XFILLER_62_544 VGND VGND VPWR VPWR sky130_fd_sc_hd__decap_3
XFILLER_62_566 VGND VGND VPWR VPWR sky130_fd_sc_hd__fill_2
XTAP_TAPCELL_ROW_66_1047 VGND VPWR sky130_fd_sc_hd__tapvpwrvgnd_1
XTAP_TAPCELL_ROW_17_455 VGND VPWR sky130_fd_sc_hd__tapvpwrvgnd_1
XFILLER_34_268 VGND VGND VPWR VPWR sky130_fd_sc_hd__decap_3
XFILLER_62_577 VGND VGND VPWR VPWR sky130_fd_sc_hd__decap_3
XTAP_TAPCELL_ROW_45_797 VGND VPWR sky130_fd_sc_hd__tapvpwrvgnd_1
XTAP_TAPCELL_ROW_45_786 VGND VPWR sky130_fd_sc_hd__tapvpwrvgnd_1
XFILLER_30_430 VGND VGND VPWR VPWR sky130_fd_sc_hd__fill_1
X_5680_ _7346_/Q hold945/X _5721_/S VGND VGND VPWR VPWR _6690_/D sky130_fd_sc_hd__mux2_2
X_4700_ _6988_/Q _5066_/A VGND VGND VPWR VPWR _5044_/A sky130_fd_sc_hd__and2_2
XFILLER_30_474 VGND VGND VPWR VPWR sky130_fd_sc_hd__fill_2
XFILLER_8_41 VGND VGND VPWR VPWR sky130_fd_sc_hd__decap_3
X_4631_ _5003_/A _4987_/A _4630_/X wire560/X VGND VGND VPWR VPWR _4631_/X sky130_fd_sc_hd__a31o_2
XFILLER_8_74 VGND VGND VPWR VPWR sky130_fd_sc_hd__decap_3
XFILLER_8_85 VGND VGND VPWR VPWR sky130_fd_sc_hd__decap_3
XFILLER_116_513 VGND VGND VPWR VPWR sky130_fd_sc_hd__decap_3
X_7350_ clkload4/A _7350_/D _6630_/Y VGND VGND VPWR VPWR _7350_/Q sky130_fd_sc_hd__dfrtp_2
X_7281_ _7322_/CLK _7281_/D _6561_/Y VGND VGND VPWR VPWR _7281_/Q sky130_fd_sc_hd__dfrtp_2
Xhold604 _6799_/Q VGND VGND VPWR VPWR _6799_/D sky130_fd_sc_hd__dlygate4sd3_1
Xhold615 _6898_/Q VGND VGND VPWR VPWR _6898_/D sky130_fd_sc_hd__dlygate4sd3_1
Xhold626 _6821_/Q VGND VGND VPWR VPWR _6821_/D sky130_fd_sc_hd__dlygate4sd3_1
X_6301_ _6644_/A VGND VGND VPWR VPWR _6301_/Y sky130_fd_sc_hd__inv_2
X_4493_ _4493_/A0 _4559_/A _4499_/S VGND VGND VPWR VPWR _7333_/D sky130_fd_sc_hd__mux2_2
XFILLER_116_557 VGND VGND VPWR VPWR sky130_fd_sc_hd__decap_3
XFILLER_6_191 VGND VGND VPWR VPWR sky130_fd_sc_hd__fill_1
XFILLER_89_408 VGND VGND VPWR VPWR sky130_fd_sc_hd__decap_3
Xclkbuf_leaf_6_clk clkload2/A VGND VGND VPWR VPWR _7267_/CLK sky130_fd_sc_hd__clkbuf_16
Xhold637 _6816_/Q VGND VGND VPWR VPWR _6816_/D sky130_fd_sc_hd__dlygate4sd3_1
Xhold648 _6866_/Q VGND VGND VPWR VPWR _6866_/D sky130_fd_sc_hd__dlygate4sd3_1
Xhold659 _6931_/Q VGND VGND VPWR VPWR _6931_/D sky130_fd_sc_hd__dlygate4sd3_1
XTAP_TAPCELL_ROW_77_1176 VGND VPWR sky130_fd_sc_hd__tapvpwrvgnd_1
XFILLER_69_110 VGND VGND VPWR VPWR sky130_fd_sc_hd__fill_2
XTAP_TAPCELL_ROW_90_1332 VGND VPWR sky130_fd_sc_hd__tapvpwrvgnd_1
XFILLER_69_143 VGND VGND VPWR VPWR sky130_fd_sc_hd__decap_3
XFILLER_97_441 VGND VGND VPWR VPWR sky130_fd_sc_hd__decap_3
X_3375_ _5118_/A _3399_/B VGND VGND VPWR VPWR _5641_/A sky130_fd_sc_hd__nand2_2
XFILLER_57_327 VGND VGND VPWR VPWR sky130_fd_sc_hd__decap_3
XFILLER_85_603 VGND VGND VPWR VPWR sky130_fd_sc_hd__decap_3
XFILLER_85_614 VGND VGND VPWR VPWR sky130_fd_sc_hd__fill_2
XFILLER_97_463 VGND VGND VPWR VPWR sky130_fd_sc_hd__fill_1
X_5114_ _5114_/A _5114_/B VGND VGND VPWR VPWR _5114_/Y sky130_fd_sc_hd__nand2_2
XFILLER_111_284 VGND VGND VPWR VPWR sky130_fd_sc_hd__decap_3
XFILLER_57_349 VGND VGND VPWR VPWR sky130_fd_sc_hd__decap_3
XFILLER_84_113 VGND VGND VPWR VPWR sky130_fd_sc_hd__fill_2
XFILLER_85_658 VGND VGND VPWR VPWR sky130_fd_sc_hd__decap_3
X_5045_ _6988_/Q _5045_/B VGND VGND VPWR VPWR _5045_/X sky130_fd_sc_hd__or2_2
XFILLER_27_28 VGND VGND VPWR VPWR sky130_fd_sc_hd__decap_3
XFILLER_84_179 VGND VGND VPWR VPWR sky130_fd_sc_hd__decap_3
XFILLER_38_585 VGND VGND VPWR VPWR sky130_fd_sc_hd__decap_3
XFILLER_65_393 VGND VGND VPWR VPWR sky130_fd_sc_hd__decap_3
X_6996_ _7341_/CLK _6996_/D _6276_/Y VGND VGND VPWR VPWR _6996_/Q sky130_fd_sc_hd__dfrtp_2
XFILLER_33_290 VGND VGND VPWR VPWR sky130_fd_sc_hd__decap_3
XFILLER_40_238 VGND VGND VPWR VPWR sky130_fd_sc_hd__decap_3
X_4829_ _4948_/A _4829_/B VGND VGND VPWR VPWR _4829_/Y sky130_fd_sc_hd__nor2_2
XFILLER_4_106 VGND VGND VPWR VPWR sky130_fd_sc_hd__decap_3
XFILLER_111_6 VGND VGND VPWR VPWR sky130_fd_sc_hd__decap_3
XFILLER_4_139 VGND VGND VPWR VPWR sky130_fd_sc_hd__fill_1
XFILLER_108_53 VGND VGND VPWR VPWR sky130_fd_sc_hd__decap_3
XFILLER_0_312 VGND VGND VPWR VPWR sky130_fd_sc_hd__fill_1
XFILLER_68_35 VGND VGND VPWR VPWR sky130_fd_sc_hd__decap_3
XFILLER_68_57 VGND VGND VPWR VPWR sky130_fd_sc_hd__decap_3
XFILLER_88_430 VGND VGND VPWR VPWR sky130_fd_sc_hd__decap_3
XFILLER_75_102 VGND VGND VPWR VPWR sky130_fd_sc_hd__decap_3
XFILLER_76_625 VGND VGND VPWR VPWR sky130_fd_sc_hd__decap_3
XFILLER_88_485 VGND VGND VPWR VPWR sky130_fd_sc_hd__decap_3
XFILLER_75_113 VGND VGND VPWR VPWR sky130_fd_sc_hd__decap_3
XFILLER_76_669 VGND VGND VPWR VPWR sky130_fd_sc_hd__decap_3
XFILLER_84_12 VGND VGND VPWR VPWR sky130_fd_sc_hd__decap_3
XFILLER_63_319 VGND VGND VPWR VPWR sky130_fd_sc_hd__decap_3
XFILLER_84_56 VGND VGND VPWR VPWR sky130_fd_sc_hd__fill_2
XFILLER_44_533 VGND VGND VPWR VPWR sky130_fd_sc_hd__decap_3
XFILLER_56_371 VGND VGND VPWR VPWR sky130_fd_sc_hd__decap_3
XFILLER_84_691 VGND VGND VPWR VPWR sky130_fd_sc_hd__fill_1
Xplace319 _4408_/A2 VGND VGND VPWR VPWR _4437_/A2 sky130_fd_sc_hd__buf_2
Xplace308 _5020_/A VGND VGND VPWR VPWR _4814_/A sky130_fd_sc_hd__buf_2
XFILLER_16_279 VGND VGND VPWR VPWR sky130_fd_sc_hd__decap_3
XFILLER_17_94 VGND VGND VPWR VPWR sky130_fd_sc_hd__decap_3
XFILLER_31_205 VGND VGND VPWR VPWR sky130_fd_sc_hd__decap_3
XFILLER_71_385 VGND VGND VPWR VPWR sky130_fd_sc_hd__decap_3
XFILLER_31_238 VGND VGND VPWR VPWR sky130_fd_sc_hd__decap_3
XFILLER_71_396 VGND VGND VPWR VPWR sky130_fd_sc_hd__decap_3
XTAP_TAPCELL_ROW_42_756 VGND VPWR sky130_fd_sc_hd__tapvpwrvgnd_1
XTAP_TAPCELL_ROW_14_425 VGND VPWR sky130_fd_sc_hd__tapvpwrvgnd_1
XTAP_TAPCELL_ROW_14_414 VGND VPWR sky130_fd_sc_hd__tapvpwrvgnd_1
XFILLER_12_485 VGND VGND VPWR VPWR sky130_fd_sc_hd__decap_3
XFILLER_33_93 VGND VGND VPWR VPWR sky130_fd_sc_hd__decap_3
XFILLER_4_651 VGND VGND VPWR VPWR sky130_fd_sc_hd__decap_3
XTAP_TAPCELL_ROW_113_1608 VGND VPWR sky130_fd_sc_hd__tapvpwrvgnd_1
XFILLER_3_161 VGND VGND VPWR VPWR sky130_fd_sc_hd__decap_3
XFILLER_4_684 VGND VGND VPWR VPWR sky130_fd_sc_hd__decap_3
XFILLER_79_452 VGND VGND VPWR VPWR sky130_fd_sc_hd__decap_3
XFILLER_67_625 VGND VGND VPWR VPWR sky130_fd_sc_hd__decap_3
XFILLER_79_474 VGND VGND VPWR VPWR sky130_fd_sc_hd__decap_3
XFILLER_66_135 VGND VGND VPWR VPWR sky130_fd_sc_hd__decap_3
XFILLER_67_658 VGND VGND VPWR VPWR sky130_fd_sc_hd__decap_3
XFILLER_79_496 VGND VGND VPWR VPWR sky130_fd_sc_hd__decap_3
XFILLER_94_433 VGND VGND VPWR VPWR sky130_fd_sc_hd__decap_3
XFILLER_47_360 VGND VGND VPWR VPWR sky130_fd_sc_hd__decap_3
XFILLER_75_691 VGND VGND VPWR VPWR sky130_fd_sc_hd__fill_1
XFILLER_82_639 VGND VGND VPWR VPWR sky130_fd_sc_hd__decap_3
XFILLER_35_533 VGND VGND VPWR VPWR sky130_fd_sc_hd__decap_3
XFILLER_47_393 VGND VGND VPWR VPWR sky130_fd_sc_hd__decap_3
XFILLER_62_330 VGND VGND VPWR VPWR sky130_fd_sc_hd__decap_3
XFILLER_74_190 VGND VGND VPWR VPWR sky130_fd_sc_hd__decap_3
X_6850_ _6911_/CLK _6850_/D VGND VGND VPWR VPWR _6850_/Q sky130_fd_sc_hd__dfxtp_2
XFILLER_90_661 VGND VGND VPWR VPWR sky130_fd_sc_hd__decap_3
X_6781_ _6964_/CLK _6781_/D VGND VGND VPWR VPWR _6781_/Q sky130_fd_sc_hd__dfxtp_2
XPHY_EDGE_ROW_8_Right_8 VGND VGND VPWR VPWR sky130_fd_sc_hd__decap_3
XFILLER_50_536 VGND VGND VPWR VPWR sky130_fd_sc_hd__decap_3
X_3993_ _4467_/B _3919_/X _3991_/X _3992_/Y VGND VGND VPWR VPWR _3993_/X sky130_fd_sc_hd__a31o_2
XFILLER_15_290 VGND VGND VPWR VPWR sky130_fd_sc_hd__decap_3
X_5663_ _5663_/A _5663_/B _5663_/C _5663_/D VGND VGND VPWR VPWR _5664_/D sky130_fd_sc_hd__nor4_2
XTAP_TAPCELL_ROW_79_1205 VGND VPWR sky130_fd_sc_hd__tapvpwrvgnd_1
X_7402_ _7403_/CLK _7402_/D _6682_/Y VGND VGND VPWR VPWR _7402_/Q sky130_fd_sc_hd__dfrtp_2
X_4614_ _4614_/A _4614_/B _4614_/C _5113_/A VGND VGND VPWR VPWR _4614_/X sky130_fd_sc_hd__and4_4
X_7333_ _7365_/CLK _7333_/D _6613_/Y VGND VGND VPWR VPWR _7333_/Q sky130_fd_sc_hd__dfrtp_2
XFILLER_116_365 VGND VGND VPWR VPWR sky130_fd_sc_hd__decap_3
X_7264_ _7264_/CLK _7264_/D _6544_/Y VGND VGND VPWR VPWR _7264_/Q sky130_fd_sc_hd__dfrtp_2
X_4476_ _4476_/A0 _4542_/A _4478_/S VGND VGND VPWR VPWR _7341_/D sky130_fd_sc_hd__mux2_2
XFILLER_89_249 VGND VGND VPWR VPWR sky130_fd_sc_hd__decap_3
X_7195_ _7279_/CLK _7195_/D _6475_/Y VGND VGND VPWR VPWR _7195_/Q sky130_fd_sc_hd__dfrtp_2
X_3427_ _3527_/A _3427_/B VGND VGND VPWR VPWR _3508_/A sky130_fd_sc_hd__nand2b_2
XPHY_EDGE_ROW_39_Right_39 VGND VGND VPWR VPWR sky130_fd_sc_hd__decap_3
XFILLER_38_27 VGND VGND VPWR VPWR sky130_fd_sc_hd__fill_1
XFILLER_57_102 VGND VGND VPWR VPWR sky130_fd_sc_hd__fill_2
X_3358_ _3339_/Y _3469_/B _3449_/A _3365_/A VGND VGND VPWR VPWR _3358_/X sky130_fd_sc_hd__o211a_4
XFILLER_112_582 VGND VGND VPWR VPWR sky130_fd_sc_hd__decap_3
XFILLER_38_49 VGND VGND VPWR VPWR sky130_fd_sc_hd__fill_2
XFILLER_58_636 VGND VGND VPWR VPWR sky130_fd_sc_hd__decap_3
XFILLER_97_293 VGND VGND VPWR VPWR sky130_fd_sc_hd__decap_3
Xhold1101 _7339_/Q VGND VGND VPWR VPWR _4480_/A0 sky130_fd_sc_hd__dlygate4sd3_1
Xhold1112 _7335_/Q VGND VGND VPWR VPWR _4488_/A0 sky130_fd_sc_hd__dlygate4sd3_1
Xhold1123 _7230_/Q VGND VGND VPWR VPWR _5196_/A sky130_fd_sc_hd__dlygate4sd3_1
XFILLER_45_308 VGND VGND VPWR VPWR sky130_fd_sc_hd__decap_3
XFILLER_58_669 VGND VGND VPWR VPWR sky130_fd_sc_hd__decap_3
XFILLER_73_617 VGND VGND VPWR VPWR sky130_fd_sc_hd__decap_3
XFILLER_85_455 VGND VGND VPWR VPWR sky130_fd_sc_hd__decap_3
Xhold1134 _7129_/Q VGND VGND VPWR VPWR _5409_/A0 sky130_fd_sc_hd__dlygate4sd3_1
Xhold1145 _7130_/Q VGND VGND VPWR VPWR _5407_/A0 sky130_fd_sc_hd__dlygate4sd3_1
Xhold1156 _7124_/Q VGND VGND VPWR VPWR _5419_/A0 sky130_fd_sc_hd__dlygate4sd3_1
Xhold1167 _7139_/Q VGND VGND VPWR VPWR _5388_/A0 sky130_fd_sc_hd__dlygate4sd3_1
XFILLER_38_371 VGND VGND VPWR VPWR sky130_fd_sc_hd__decap_3
XFILLER_85_488 VGND VGND VPWR VPWR sky130_fd_sc_hd__decap_3
Xhold1178 _7174_/Q VGND VGND VPWR VPWR _5312_/A0 sky130_fd_sc_hd__dlygate4sd3_1
Xhold1189 _7227_/Q VGND VGND VPWR VPWR _5203_/A sky130_fd_sc_hd__dlygate4sd3_1
X_5028_ _5028_/A0 _5027_/X _5028_/S VGND VGND VPWR VPWR _7260_/D sky130_fd_sc_hd__mux2_2
XFILLER_26_533 VGND VGND VPWR VPWR sky130_fd_sc_hd__decap_3
XFILLER_53_330 VGND VGND VPWR VPWR sky130_fd_sc_hd__decap_3
XFILLER_54_15 VGND VGND VPWR VPWR sky130_fd_sc_hd__decap_3
XFILLER_65_190 VGND VGND VPWR VPWR sky130_fd_sc_hd__decap_3
XFILLER_13_205 VGND VGND VPWR VPWR sky130_fd_sc_hd__fill_1
XFILLER_53_374 VGND VGND VPWR VPWR sky130_fd_sc_hd__decap_3
XFILLER_54_59 VGND VGND VPWR VPWR sky130_fd_sc_hd__decap_3
XFILLER_81_661 VGND VGND VPWR VPWR sky130_fd_sc_hd__decap_3
XFILLER_110_21 VGND VGND VPWR VPWR sky130_fd_sc_hd__decap_3
XFILLER_110_32 VGND VGND VPWR VPWR sky130_fd_sc_hd__decap_3
XFILLER_13_249 VGND VGND VPWR VPWR sky130_fd_sc_hd__decap_3
XFILLER_41_547 VGND VGND VPWR VPWR sky130_fd_sc_hd__decap_3
XFILLER_53_385 VGND VGND VPWR VPWR sky130_fd_sc_hd__decap_3
XFILLER_53_396 VGND VGND VPWR VPWR sky130_fd_sc_hd__decap_3
XFILLER_80_171 VGND VGND VPWR VPWR sky130_fd_sc_hd__decap_3
X_6979_ _7330_/CLK _6979_/D _6259_/Y VGND VGND VPWR VPWR _6979_/Q sky130_fd_sc_hd__dfrtp_2
XPHY_EDGE_ROW_48_Right_48 VGND VGND VPWR VPWR sky130_fd_sc_hd__decap_3
XFILLER_110_65 VGND VGND VPWR VPWR sky130_fd_sc_hd__decap_3
XFILLER_21_271 VGND VGND VPWR VPWR sky130_fd_sc_hd__decap_3
XFILLER_21_293 VGND VGND VPWR VPWR sky130_fd_sc_hd__decap_3
XFILLER_5_404 VGND VGND VPWR VPWR sky130_fd_sc_hd__decap_3
XFILLER_107_310 VGND VGND VPWR VPWR sky130_fd_sc_hd__decap_3
XFILLER_107_354 VGND VGND VPWR VPWR sky130_fd_sc_hd__decap_3
XFILLER_79_78 VGND VGND VPWR VPWR sky130_fd_sc_hd__decap_3
XPHY_EDGE_ROW_57_Right_57 VGND VGND VPWR VPWR sky130_fd_sc_hd__decap_3
XFILLER_1_632 VGND VGND VPWR VPWR sky130_fd_sc_hd__decap_3
Xhold990 _7211_/Q VGND VGND VPWR VPWR hold990/X sky130_fd_sc_hd__dlygate4sd3_1
XFILLER_1_665 VGND VGND VPWR VPWR sky130_fd_sc_hd__decap_3
XFILLER_1_676 VGND VGND VPWR VPWR sky130_fd_sc_hd__decap_3
XFILLER_49_614 VGND VGND VPWR VPWR sky130_fd_sc_hd__fill_2
XFILLER_95_208 VGND VGND VPWR VPWR sky130_fd_sc_hd__fill_2
XFILLER_95_219 VGND VGND VPWR VPWR sky130_fd_sc_hd__fill_2
XFILLER_0_175 VGND VGND VPWR VPWR sky130_fd_sc_hd__fill_1
XFILLER_0_197 VGND VGND VPWR VPWR sky130_fd_sc_hd__fill_1
XFILLER_103_582 VGND VGND VPWR VPWR sky130_fd_sc_hd__decap_3
XFILLER_48_135 VGND VGND VPWR VPWR sky130_fd_sc_hd__decap_3
XFILLER_49_647 VGND VGND VPWR VPWR sky130_fd_sc_hd__decap_3
XFILLER_95_44 VGND VGND VPWR VPWR sky130_fd_sc_hd__decap_3
XFILLER_95_66 VGND VGND VPWR VPWR sky130_fd_sc_hd__decap_3
XFILLER_48_168 VGND VGND VPWR VPWR sky130_fd_sc_hd__decap_3
XFILLER_76_477 VGND VGND VPWR VPWR sky130_fd_sc_hd__fill_2
XFILLER_95_99 VGND VGND VPWR VPWR sky130_fd_sc_hd__decap_3
XFILLER_28_60 VGND VGND VPWR VPWR sky130_fd_sc_hd__decap_3
XFILLER_57_691 VGND VGND VPWR VPWR sky130_fd_sc_hd__fill_1
XFILLER_63_105 VGND VGND VPWR VPWR sky130_fd_sc_hd__decap_3
XFILLER_63_127 VGND VGND VPWR VPWR sky130_fd_sc_hd__decap_3
XFILLER_64_628 VGND VGND VPWR VPWR sky130_fd_sc_hd__decap_3
XTAP_TAPCELL_ROW_47_815 VGND VPWR sky130_fd_sc_hd__tapvpwrvgnd_1
XFILLER_29_393 VGND VGND VPWR VPWR sky130_fd_sc_hd__decap_3
XFILLER_44_330 VGND VGND VPWR VPWR sky130_fd_sc_hd__decap_3
XFILLER_91_447 VGND VGND VPWR VPWR sky130_fd_sc_hd__fill_1
XFILLER_44_363 VGND VGND VPWR VPWR sky130_fd_sc_hd__fill_1
XTAP_TAPCELL_ROW_63_1006 VGND VPWR sky130_fd_sc_hd__tapvpwrvgnd_1
XPHY_EDGE_ROW_66_Right_66 VGND VGND VPWR VPWR sky130_fd_sc_hd__decap_3
XFILLER_44_70 VGND VGND VPWR VPWR sky130_fd_sc_hd__fill_1
XTAP_TAPCELL_ROW_27_572 VGND VPWR sky130_fd_sc_hd__tapvpwrvgnd_1
XFILLER_8_220 VGND VGND VPWR VPWR sky130_fd_sc_hd__decap_3
XFILLER_8_253 VGND VGND VPWR VPWR sky130_fd_sc_hd__decap_3
XFILLER_60_80 VGND VGND VPWR VPWR sky130_fd_sc_hd__decap_3
XFILLER_60_91 VGND VGND VPWR VPWR sky130_fd_sc_hd__decap_3
XFILLER_8_286 VGND VGND VPWR VPWR sky130_fd_sc_hd__decap_3
Xoutput517 _5229_/B VGND VGND VPWR VPWR instruction_out[7] sky130_fd_sc_hd__clkdlybuf4s25_1
Xoutput506 _4530_/S VGND VGND VPWR VPWR instruction_out[24] sky130_fd_sc_hd__clkdlybuf4s25_1
XPHY_EDGE_ROW_75_Right_75 VGND VGND VPWR VPWR sky130_fd_sc_hd__decap_3
XFILLER_99_503 VGND VGND VPWR VPWR sky130_fd_sc_hd__fill_1
XFILLER_113_302 VGND VGND VPWR VPWR sky130_fd_sc_hd__decap_3
XFILLER_4_470 VGND VGND VPWR VPWR sky130_fd_sc_hd__decap_3
XFILLER_5_42 VGND VGND VPWR VPWR sky130_fd_sc_hd__decap_3
Xoutput539 _7004_/Q VGND VGND VPWR VPWR pc_out[27] sky130_fd_sc_hd__clkdlybuf4s25_1
Xoutput528 _6994_/Q VGND VGND VPWR VPWR pc_out[17] sky130_fd_sc_hd__clkdlybuf4s25_1
X_4330_ _5057_/B _4330_/B VGND VGND VPWR VPWR _4619_/B sky130_fd_sc_hd__or2_2
XTAP_TAPCELL_ROW_74_1135 VGND VPWR sky130_fd_sc_hd__tapvpwrvgnd_1
XFILLER_5_75 VGND VGND VPWR VPWR sky130_fd_sc_hd__decap_3
X_4261_ _7358_/Q _4346_/B1 _3366_/X _7166_/Q _4248_/A VGND VGND VPWR VPWR _4261_/X
+ sky130_fd_sc_hd__a221o_2
XFILLER_99_569 VGND VGND VPWR VPWR sky130_fd_sc_hd__decap_3
XFILLER_99_558 VGND VGND VPWR VPWR sky130_fd_sc_hd__fill_2
XFILLER_101_508 VGND VGND VPWR VPWR sky130_fd_sc_hd__decap_3
XFILLER_113_379 VGND VGND VPWR VPWR sky130_fd_sc_hd__decap_3
XFILLER_86_208 VGND VGND VPWR VPWR sky130_fd_sc_hd__decap_3
XFILLER_39_102 VGND VGND VPWR VPWR sky130_fd_sc_hd__decap_3
XFILLER_39_113 VGND VGND VPWR VPWR sky130_fd_sc_hd__decap_3
XFILLER_79_271 VGND VGND VPWR VPWR sky130_fd_sc_hd__decap_3
XFILLER_79_293 VGND VGND VPWR VPWR sky130_fd_sc_hd__decap_3
X_4192_ _4637_/B _4637_/C VGND VGND VPWR VPWR _4380_/A sky130_fd_sc_hd__and2_2
XFILLER_39_146 VGND VGND VPWR VPWR sky130_fd_sc_hd__decap_3
XFILLER_55_606 VGND VGND VPWR VPWR sky130_fd_sc_hd__decap_3
XFILLER_55_617 VGND VGND VPWR VPWR sky130_fd_sc_hd__decap_3
XFILLER_67_444 VGND VGND VPWR VPWR sky130_fd_sc_hd__decap_3
XFILLER_27_319 VGND VGND VPWR VPWR sky130_fd_sc_hd__decap_3
XFILLER_54_127 VGND VGND VPWR VPWR sky130_fd_sc_hd__decap_3
XFILLER_94_274 VGND VGND VPWR VPWR sky130_fd_sc_hd__decap_3
XPHY_EDGE_ROW_84_Right_84 VGND VGND VPWR VPWR sky130_fd_sc_hd__decap_3
XPHY_EDGE_ROW_19_Left_136 VGND VGND VPWR VPWR sky130_fd_sc_hd__decap_3
XFILLER_63_650 VGND VGND VPWR VPWR sky130_fd_sc_hd__decap_3
X_6902_ _6966_/CLK _6902_/D VGND VGND VPWR VPWR _6902_/Q sky130_fd_sc_hd__dfxtp_2
XFILLER_23_503 VGND VGND VPWR VPWR sky130_fd_sc_hd__fill_1
XFILLER_62_160 VGND VGND VPWR VPWR sky130_fd_sc_hd__decap_3
X_6833_ _6978_/CLK _6833_/D VGND VGND VPWR VPWR _6833_/Q sky130_fd_sc_hd__dfxtp_2
XTAP_TAPCELL_ROW_85_1275 VGND VPWR sky130_fd_sc_hd__tapvpwrvgnd_1
XFILLER_24_29 VGND VGND VPWR VPWR sky130_fd_sc_hd__decap_3
XFILLER_35_396 VGND VGND VPWR VPWR sky130_fd_sc_hd__decap_3
XFILLER_62_193 VGND VGND VPWR VPWR sky130_fd_sc_hd__decap_3
XFILLER_23_569 VGND VGND VPWR VPWR sky130_fd_sc_hd__fill_2
X_6764_ _6976_/CLK _6764_/D VGND VGND VPWR VPWR _6764_/Q sky130_fd_sc_hd__dfxtp_2
XFILLER_10_208 VGND VGND VPWR VPWR sky130_fd_sc_hd__decap_3
XFILLER_10_219 VGND VGND VPWR VPWR sky130_fd_sc_hd__decap_3
XFILLER_50_377 VGND VGND VPWR VPWR sky130_fd_sc_hd__decap_3
X_6695_ clkload4/A _6695_/D VGND VGND VPWR VPWR _6695_/Q sky130_fd_sc_hd__dfxtp_2
X_5715_ _7363_/Q hold929/X _5737_/S VGND VGND VPWR VPWR _6707_/D sky130_fd_sc_hd__mux2_2
XFILLER_108_107 VGND VGND VPWR VPWR sky130_fd_sc_hd__decap_3
X_5646_ _5646_/A VGND VGND VPWR VPWR _5646_/Y sky130_fd_sc_hd__inv_2
XPHY_EDGE_ROW_28_Left_145 VGND VGND VPWR VPWR sky130_fd_sc_hd__decap_3
XPHY_EDGE_ROW_93_Right_93 VGND VGND VPWR VPWR sky130_fd_sc_hd__decap_3
X_5577_ _5577_/A0 _5038_/X _5595_/B VGND VGND VPWR VPWR _7040_/D sky130_fd_sc_hd__mux2_2
XFILLER_104_302 VGND VGND VPWR VPWR sky130_fd_sc_hd__decap_3
XFILLER_2_407 VGND VGND VPWR VPWR sky130_fd_sc_hd__decap_3
X_7316_ clkload5/A _7316_/D _6596_/Y VGND VGND VPWR VPWR _7316_/Q sky130_fd_sc_hd__dfrtp_2
X_4528_ _4528_/A _4528_/B VGND VGND VPWR VPWR _7315_/D sky130_fd_sc_hd__or2_2
XFILLER_49_15 VGND VGND VPWR VPWR sky130_fd_sc_hd__fill_2
XFILLER_6_9 VGND VGND VPWR VPWR sky130_fd_sc_hd__decap_3
X_7247_ _7356_/CLK _7247_/D _6527_/Y VGND VGND VPWR VPWR _7247_/Q sky130_fd_sc_hd__dfrtp_2
X_4459_ _4040_/Y _4457_/X _4458_/X _4459_/C1 VGND VGND VPWR VPWR _5655_/B sky130_fd_sc_hd__o211a_2
XFILLER_104_368 VGND VGND VPWR VPWR sky130_fd_sc_hd__decap_3
XFILLER_105_21 VGND VGND VPWR VPWR sky130_fd_sc_hd__decap_3
X_7178_ _7338_/CLK _7178_/D _6458_/Y VGND VGND VPWR VPWR _7178_/Q sky130_fd_sc_hd__dfrtp_2
XFILLER_105_54 VGND VGND VPWR VPWR sky130_fd_sc_hd__fill_2
XFILLER_46_606 VGND VGND VPWR VPWR sky130_fd_sc_hd__decap_3
XFILLER_85_252 VGND VGND VPWR VPWR sky130_fd_sc_hd__fill_2
XPHY_EDGE_ROW_37_Left_154 VGND VGND VPWR VPWR sky130_fd_sc_hd__decap_3
XFILLER_105_87 VGND VGND VPWR VPWR sky130_fd_sc_hd__decap_3
XFILLER_46_639 VGND VGND VPWR VPWR sky130_fd_sc_hd__decap_3
XFILLER_58_499 VGND VGND VPWR VPWR sky130_fd_sc_hd__decap_3
XFILLER_65_47 VGND VGND VPWR VPWR sky130_fd_sc_hd__fill_1
XFILLER_73_414 VGND VGND VPWR VPWR sky130_fd_sc_hd__decap_3
XFILLER_73_436 VGND VGND VPWR VPWR sky130_fd_sc_hd__decap_3
XFILLER_39_691 VGND VGND VPWR VPWR sky130_fd_sc_hd__fill_1
XFILLER_45_138 VGND VGND VPWR VPWR sky130_fd_sc_hd__decap_3
XFILLER_73_458 VGND VGND VPWR VPWR sky130_fd_sc_hd__decap_3
XFILLER_54_672 VGND VGND VPWR VPWR sky130_fd_sc_hd__decap_3
XFILLER_14_536 VGND VGND VPWR VPWR sky130_fd_sc_hd__decap_3
XFILLER_41_311 VGND VGND VPWR VPWR sky130_fd_sc_hd__decap_3
XFILLER_53_160 VGND VGND VPWR VPWR sky130_fd_sc_hd__decap_3
XFILLER_81_24 VGND VGND VPWR VPWR sky130_fd_sc_hd__decap_3
XFILLER_41_355 VGND VGND VPWR VPWR sky130_fd_sc_hd__decap_3
XFILLER_81_57 VGND VGND VPWR VPWR sky130_fd_sc_hd__decap_3
XTAP_TAPCELL_ROW_24_542 VGND VPWR sky130_fd_sc_hd__tapvpwrvgnd_1
XFILLER_81_79 VGND VGND VPWR VPWR sky130_fd_sc_hd__fill_1
XTAP_TAPCELL_ROW_52_873 VGND VPWR sky130_fd_sc_hd__tapvpwrvgnd_1
XPHY_EDGE_ROW_46_Left_163 VGND VGND VPWR VPWR sky130_fd_sc_hd__decap_3
XFILLER_108_663 VGND VGND VPWR VPWR sky130_fd_sc_hd__decap_3
XFILLER_30_83 VGND VGND VPWR VPWR sky130_fd_sc_hd__fill_1
XFILLER_5_278 VGND VGND VPWR VPWR sky130_fd_sc_hd__fill_2
XFILLER_107_184 VGND VGND VPWR VPWR sky130_fd_sc_hd__decap_3
XFILLER_1_440 VGND VGND VPWR VPWR sky130_fd_sc_hd__decap_3
XFILLER_39_9 VGND VGND VPWR VPWR sky130_fd_sc_hd__fill_2
XPHY_EDGE_ROW_55_Left_172 VGND VGND VPWR VPWR sky130_fd_sc_hd__decap_3
XFILLER_39_70 VGND VGND VPWR VPWR sky130_fd_sc_hd__decap_3
XFILLER_49_466 VGND VGND VPWR VPWR sky130_fd_sc_hd__decap_3
XFILLER_36_105 VGND VGND VPWR VPWR sky130_fd_sc_hd__decap_3
XFILLER_37_617 VGND VGND VPWR VPWR sky130_fd_sc_hd__decap_3
XFILLER_91_211 VGND VGND VPWR VPWR sky130_fd_sc_hd__decap_3
XFILLER_29_190 VGND VGND VPWR VPWR sky130_fd_sc_hd__decap_3
XFILLER_64_436 VGND VGND VPWR VPWR sky130_fd_sc_hd__fill_1
XFILLER_64_447 VGND VGND VPWR VPWR sky130_fd_sc_hd__decap_3
XFILLER_64_469 VGND VGND VPWR VPWR sky130_fd_sc_hd__decap_3
XFILLER_45_650 VGND VGND VPWR VPWR sky130_fd_sc_hd__decap_3
XFILLER_51_119 VGND VGND VPWR VPWR sky130_fd_sc_hd__decap_3
XFILLER_91_255 VGND VGND VPWR VPWR sky130_fd_sc_hd__decap_3
XFILLER_17_396 VGND VGND VPWR VPWR sky130_fd_sc_hd__decap_3
XFILLER_44_182 VGND VGND VPWR VPWR sky130_fd_sc_hd__decap_3
XFILLER_60_631 VGND VGND VPWR VPWR sky130_fd_sc_hd__decap_3
XFILLER_32_355 VGND VGND VPWR VPWR sky130_fd_sc_hd__decap_3
XFILLER_60_675 VGND VGND VPWR VPWR sky130_fd_sc_hd__decap_3
X_3830_ _6860_/Q _3883_/A2 _3913_/B1 _6852_/Q _3829_/X VGND VGND VPWR VPWR _3830_/X
+ sky130_fd_sc_hd__a221o_2
XPHY_EDGE_ROW_64_Left_181 VGND VGND VPWR VPWR sky130_fd_sc_hd__decap_3
XFILLER_32_377 VGND VGND VPWR VPWR sky130_fd_sc_hd__decap_3
XFILLER_32_388 VGND VGND VPWR VPWR sky130_fd_sc_hd__decap_3
XFILLER_72_3 VGND VGND VPWR VPWR sky130_fd_sc_hd__decap_3
X_6480_ _6644_/A VGND VGND VPWR VPWR _6480_/Y sky130_fd_sc_hd__inv_2
X_3692_ _6715_/Q _3767_/A2 _3826_/B1 _6893_/Q _3691_/X VGND VGND VPWR VPWR _3692_/X
+ sky130_fd_sc_hd__a221o_2
XFILLER_114_622 VGND VGND VPWR VPWR sky130_fd_sc_hd__decap_3
X_5362_ _3378_/A _5646_/A _5362_/C VGND VGND VPWR VPWR _5396_/S sky130_fd_sc_hd__and3b_2
XFILLER_99_311 VGND VGND VPWR VPWR sky130_fd_sc_hd__decap_3
X_7101_ _7279_/CLK _7101_/D _6381_/Y VGND VGND VPWR VPWR _7101_/Q sky130_fd_sc_hd__dfrtp_2
X_4313_ _4376_/A _4364_/A _4364_/B _4313_/D VGND VGND VPWR VPWR _4315_/A sky130_fd_sc_hd__or4_4
XPHY_EDGE_ROW_73_Left_190 VGND VGND VPWR VPWR sky130_fd_sc_hd__decap_3
XFILLER_101_305 VGND VGND VPWR VPWR sky130_fd_sc_hd__decap_3
XFILLER_113_143 VGND VGND VPWR VPWR sky130_fd_sc_hd__decap_3
XFILLER_114_666 VGND VGND VPWR VPWR sky130_fd_sc_hd__decap_3
XFILLER_87_517 VGND VGND VPWR VPWR sky130_fd_sc_hd__fill_1
X_7032_ clkload4/A _7032_/D _6312_/Y VGND VGND VPWR VPWR _7032_/Q sky130_fd_sc_hd__dfrtp_2
XFILLER_99_366 VGND VGND VPWR VPWR sky130_fd_sc_hd__decap_3
XFILLER_113_187 VGND VGND VPWR VPWR sky130_fd_sc_hd__decap_3
XFILLER_19_29 VGND VGND VPWR VPWR sky130_fd_sc_hd__decap_3
X_4244_ _7293_/Q _4517_/S VGND VGND VPWR VPWR _4244_/X sky130_fd_sc_hd__and2_2
XFILLER_99_399 VGND VGND VPWR VPWR sky130_fd_sc_hd__fill_1
XFILLER_101_349 VGND VGND VPWR VPWR sky130_fd_sc_hd__decap_3
XFILLER_67_241 VGND VGND VPWR VPWR sky130_fd_sc_hd__decap_3
XFILLER_95_550 VGND VGND VPWR VPWR sky130_fd_sc_hd__fill_2
XFILLER_95_561 VGND VGND VPWR VPWR sky130_fd_sc_hd__decap_3
X_4175_ _7328_/Q _3962_/S _4419_/C1 _4174_/X VGND VGND VPWR VPWR _4175_/X sky130_fd_sc_hd__a211o_2
XFILLER_27_116 VGND VGND VPWR VPWR sky130_fd_sc_hd__decap_3
XFILLER_82_200 VGND VGND VPWR VPWR sky130_fd_sc_hd__decap_3
XFILLER_55_447 VGND VGND VPWR VPWR sky130_fd_sc_hd__fill_1
XFILLER_35_17 VGND VGND VPWR VPWR sky130_fd_sc_hd__decap_3
XFILLER_55_469 VGND VGND VPWR VPWR sky130_fd_sc_hd__decap_3
XFILLER_42_119 VGND VGND VPWR VPWR sky130_fd_sc_hd__fill_1
XFILLER_51_620 VGND VGND VPWR VPWR sky130_fd_sc_hd__decap_3
XFILLER_82_299 VGND VGND VPWR VPWR sky130_fd_sc_hd__decap_3
XFILLER_35_193 VGND VGND VPWR VPWR sky130_fd_sc_hd__decap_3
XFILLER_51_653 VGND VGND VPWR VPWR sky130_fd_sc_hd__decap_3
X_6816_ _6929_/CLK _6816_/D VGND VGND VPWR VPWR _6816_/Q sky130_fd_sc_hd__dfxtp_2
XFILLER_23_399 VGND VGND VPWR VPWR sky130_fd_sc_hd__fill_1
XFILLER_50_174 VGND VGND VPWR VPWR sky130_fd_sc_hd__decap_3
XFILLER_51_27 VGND VGND VPWR VPWR sky130_fd_sc_hd__decap_3
X_6747_ _6911_/CLK _6747_/D VGND VGND VPWR VPWR _6747_/Q sky130_fd_sc_hd__dfxtp_2
XTAP_TAPCELL_ROW_21_501 VGND VPWR sky130_fd_sc_hd__tapvpwrvgnd_1
XFILLER_109_405 VGND VGND VPWR VPWR sky130_fd_sc_hd__decap_3
XTAP_TAPCELL_ROW_98_1422 VGND VPWR sky130_fd_sc_hd__tapvpwrvgnd_1
X_6678_ _6684_/A VGND VGND VPWR VPWR _6678_/Y sky130_fd_sc_hd__inv_2
XTAP_TAPCELL_ROW_98_1433 VGND VPWR sky130_fd_sc_hd__tapvpwrvgnd_1
XFILLER_105_655 VGND VGND VPWR VPWR sky130_fd_sc_hd__decap_3
XFILLER_4_6 VGND VGND VPWR VPWR sky130_fd_sc_hd__decap_3
XFILLER_105_688 VGND VGND VPWR VPWR sky130_fd_sc_hd__decap_3
XFILLER_2_259 VGND VGND VPWR VPWR sky130_fd_sc_hd__decap_3
XFILLER_78_528 VGND VGND VPWR VPWR sky130_fd_sc_hd__decap_3
XFILLER_116_53 VGND VGND VPWR VPWR sky130_fd_sc_hd__decap_3
XFILLER_116_97 VGND VGND VPWR VPWR sky130_fd_sc_hd__decap_3
XFILLER_58_230 VGND VGND VPWR VPWR sky130_fd_sc_hd__decap_3
XFILLER_46_403 VGND VGND VPWR VPWR sky130_fd_sc_hd__decap_3
XFILLER_76_79 VGND VGND VPWR VPWR sky130_fd_sc_hd__decap_3
XTAP_TAPCELL_ROW_29_601 VGND VPWR sky130_fd_sc_hd__tapvpwrvgnd_1
XFILLER_18_127 VGND VGND VPWR VPWR sky130_fd_sc_hd__decap_3
XFILLER_46_458 VGND VGND VPWR VPWR sky130_fd_sc_hd__decap_3
XFILLER_92_12 VGND VGND VPWR VPWR sky130_fd_sc_hd__decap_3
XTAP_TAPCELL_ROW_57_932 VGND VPWR sky130_fd_sc_hd__tapvpwrvgnd_1
XFILLER_27_650 VGND VGND VPWR VPWR sky130_fd_sc_hd__decap_3
XFILLER_33_108 VGND VGND VPWR VPWR sky130_fd_sc_hd__decap_3
XFILLER_61_417 VGND VGND VPWR VPWR sky130_fd_sc_hd__decap_3
XFILLER_73_255 VGND VGND VPWR VPWR sky130_fd_sc_hd__decap_3
XFILLER_73_266 VGND VGND VPWR VPWR sky130_fd_sc_hd__decap_3
XTAP_TAPCELL_ROW_107_1540 VGND VPWR sky130_fd_sc_hd__tapvpwrvgnd_1
XFILLER_26_171 VGND VGND VPWR VPWR sky130_fd_sc_hd__decap_3
XFILLER_33_119 VGND VGND VPWR VPWR sky130_fd_sc_hd__fill_2
XFILLER_42_631 VGND VGND VPWR VPWR sky130_fd_sc_hd__decap_3
XFILLER_14_333 VGND VGND VPWR VPWR sky130_fd_sc_hd__decap_3
XFILLER_25_50 VGND VGND VPWR VPWR sky130_fd_sc_hd__decap_3
XFILLER_42_675 VGND VGND VPWR VPWR sky130_fd_sc_hd__decap_3
XFILLER_10_550 VGND VGND VPWR VPWR sky130_fd_sc_hd__decap_3
XFILLER_41_60 VGND VGND VPWR VPWR sky130_fd_sc_hd__decap_3
XFILLER_41_71 VGND VGND VPWR VPWR sky130_fd_sc_hd__decap_3
XFILLER_111_603 VGND VGND VPWR VPWR sky130_fd_sc_hd__decap_3
XTAP_TAPCELL_ROW_71_1105 VGND VPWR sky130_fd_sc_hd__tapvpwrvgnd_1
XFILLER_111_647 VGND VGND VPWR VPWR sky130_fd_sc_hd__decap_3
XFILLER_37_6 VGND VGND VPWR VPWR sky130_fd_sc_hd__decap_3
XFILLER_1_281 VGND VGND VPWR VPWR sky130_fd_sc_hd__fill_1
XFILLER_2_32 VGND VGND VPWR VPWR sky130_fd_sc_hd__decap_3
XFILLER_77_550 VGND VGND VPWR VPWR sky130_fd_sc_hd__decap_3
XFILLER_96_347 VGND VGND VPWR VPWR sky130_fd_sc_hd__decap_3
XFILLER_110_168 VGND VGND VPWR VPWR sky130_fd_sc_hd__decap_3
XFILLER_2_65 VGND VGND VPWR VPWR sky130_fd_sc_hd__decap_3
XFILLER_49_252 VGND VGND VPWR VPWR sky130_fd_sc_hd__decap_3
XFILLER_77_561 VGND VGND VPWR VPWR sky130_fd_sc_hd__decap_3
XFILLER_77_583 VGND VGND VPWR VPWR sky130_fd_sc_hd__fill_2
XFILLER_37_458 VGND VGND VPWR VPWR sky130_fd_sc_hd__decap_3
XFILLER_64_222 VGND VGND VPWR VPWR sky130_fd_sc_hd__decap_3
XFILLER_92_520 VGND VGND VPWR VPWR sky130_fd_sc_hd__decap_3
XFILLER_52_417 VGND VGND VPWR VPWR sky130_fd_sc_hd__decap_3
XFILLER_64_244 VGND VGND VPWR VPWR sky130_fd_sc_hd__decap_3
XFILLER_64_266 VGND VGND VPWR VPWR sky130_fd_sc_hd__decap_3
XFILLER_92_564 VGND VGND VPWR VPWR sky130_fd_sc_hd__decap_3
XTAP_TAPCELL_ROW_69_1078 VGND VPWR sky130_fd_sc_hd__tapvpwrvgnd_1
XFILLER_24_119 VGND VGND VPWR VPWR sky130_fd_sc_hd__decap_3
XFILLER_52_439 VGND VGND VPWR VPWR sky130_fd_sc_hd__fill_2
X_4931_ _4931_/A _4931_/B VGND VGND VPWR VPWR _6996_/D sky130_fd_sc_hd__nor2_2
XFILLER_17_193 VGND VGND VPWR VPWR sky130_fd_sc_hd__decap_3
XFILLER_32_141 VGND VGND VPWR VPWR sky130_fd_sc_hd__decap_3
XFILLER_33_653 VGND VGND VPWR VPWR sky130_fd_sc_hd__decap_3
X_4862_ _4825_/B _4862_/B VGND VGND VPWR VPWR _7000_/D sky130_fd_sc_hd__and2b_2
XTAP_TAPCELL_ROW_82_1234 VGND VPWR sky130_fd_sc_hd__tapvpwrvgnd_1
X_6601_ _6637_/A VGND VGND VPWR VPWR _6601_/Y sky130_fd_sc_hd__inv_2
X_3813_ _3802_/X _3812_/X _3896_/B1 VGND VGND VPWR VPWR _3813_/Y sky130_fd_sc_hd__o21ai_2
XFILLER_32_185 VGND VGND VPWR VPWR sky130_fd_sc_hd__fill_2
X_4793_ _4793_/A0 _4792_/X _4865_/S VGND VGND VPWR VPWR _7274_/D sky130_fd_sc_hd__mux2_2
X_6532_ _6532_/A VGND VGND VPWR VPWR _6532_/Y sky130_fd_sc_hd__inv_2
X_3744_ _6728_/Q _3892_/A2 _3656_/Y _6973_/Q VGND VGND VPWR VPWR _3744_/X sky130_fd_sc_hd__a22o_2
X_6463_ _6672_/A VGND VGND VPWR VPWR _6463_/Y sky130_fd_sc_hd__inv_2
X_6394_ _6553_/A VGND VGND VPWR VPWR _6394_/Y sky130_fd_sc_hd__inv_2
XTAP_TAPCELL_ROW_93_1363 VGND VPWR sky130_fd_sc_hd__tapvpwrvgnd_1
XFILLER_101_113 VGND VGND VPWR VPWR sky130_fd_sc_hd__decap_3
XFILLER_102_625 VGND VGND VPWR VPWR sky130_fd_sc_hd__fill_1
X_5276_ _5276_/A0 _5094_/X _5292_/S VGND VGND VPWR VPWR _7192_/D sky130_fd_sc_hd__mux2_2
XFILLER_101_146 VGND VGND VPWR VPWR sky130_fd_sc_hd__fill_1
XFILLER_102_669 VGND VGND VPWR VPWR sky130_fd_sc_hd__decap_3
X_7015_ _7279_/CLK _7015_/D _6295_/Y VGND VGND VPWR VPWR _7015_/Q sky130_fd_sc_hd__dfrtp_2
X_4227_ _7355_/Q _3449_/X _4352_/B1 _7163_/Q VGND VGND VPWR VPWR _4227_/X sky130_fd_sc_hd__a22o_2
XFILLER_68_572 VGND VGND VPWR VPWR sky130_fd_sc_hd__decap_3
XFILLER_46_27 VGND VGND VPWR VPWR sky130_fd_sc_hd__fill_1
XFILLER_46_49 VGND VGND VPWR VPWR sky130_fd_sc_hd__fill_2
XFILLER_55_233 VGND VGND VPWR VPWR sky130_fd_sc_hd__decap_3
XFILLER_83_531 VGND VGND VPWR VPWR sky130_fd_sc_hd__decap_3
X_4158_ _4158_/A _4158_/B VGND VGND VPWR VPWR _4920_/A sky130_fd_sc_hd__nand2_2
XFILLER_55_266 VGND VGND VPWR VPWR sky130_fd_sc_hd__decap_3
XFILLER_83_553 VGND VGND VPWR VPWR sky130_fd_sc_hd__decap_3
X_4089_ _7206_/Q _3949_/S _4429_/B1 _7398_/Q VGND VGND VPWR VPWR _4089_/X sky130_fd_sc_hd__a22o_2
XTAP_TAPCELL_ROW_54_902 VGND VPWR sky130_fd_sc_hd__tapvpwrvgnd_1
XFILLER_36_480 VGND VGND VPWR VPWR sky130_fd_sc_hd__fill_1
XFILLER_55_299 VGND VGND VPWR VPWR sky130_fd_sc_hd__decap_3
XFILLER_70_203 VGND VGND VPWR VPWR sky130_fd_sc_hd__decap_3
XFILLER_102_88 VGND VGND VPWR VPWR sky130_fd_sc_hd__decap_3
XFILLER_24_653 VGND VGND VPWR VPWR sky130_fd_sc_hd__decap_3
XFILLER_62_26 VGND VGND VPWR VPWR sky130_fd_sc_hd__fill_2
XFILLER_11_314 VGND VGND VPWR VPWR sky130_fd_sc_hd__decap_3
XFILLER_23_141 VGND VGND VPWR VPWR sky130_fd_sc_hd__fill_1
XFILLER_23_163 VGND VGND VPWR VPWR sky130_fd_sc_hd__decap_3
XFILLER_62_59 VGND VGND VPWR VPWR sky130_fd_sc_hd__decap_3
XTAP_TAPCELL_ROW_62_990 VGND VPWR sky130_fd_sc_hd__tapvpwrvgnd_1
XTAP_TAPCELL_ROW_102_1481 VGND VPWR sky130_fd_sc_hd__tapvpwrvgnd_1
XTAP_TAPCELL_ROW_102_1470 VGND VPWR sky130_fd_sc_hd__tapvpwrvgnd_1
XFILLER_109_202 VGND VGND VPWR VPWR sky130_fd_sc_hd__decap_3
XFILLER_11_358 VGND VGND VPWR VPWR sky130_fd_sc_hd__fill_1
XFILLER_7_307 VGND VGND VPWR VPWR sky130_fd_sc_hd__fill_1
XFILLER_7_329 VGND VGND VPWR VPWR sky130_fd_sc_hd__decap_3
XFILLER_11_30 VGND VGND VPWR VPWR sky130_fd_sc_hd__decap_3
XFILLER_11_63 VGND VGND VPWR VPWR sky130_fd_sc_hd__decap_3
XFILLER_11_85 VGND VGND VPWR VPWR sky130_fd_sc_hd__decap_3
XFILLER_3_513 VGND VGND VPWR VPWR sky130_fd_sc_hd__fill_2
XFILLER_105_441 VGND VGND VPWR VPWR sky130_fd_sc_hd__decap_3
XFILLER_3_557 VGND VGND VPWR VPWR sky130_fd_sc_hd__decap_3
XFILLER_3_579 VGND VGND VPWR VPWR sky130_fd_sc_hd__fill_1
XFILLER_87_12 VGND VGND VPWR VPWR sky130_fd_sc_hd__decap_3
XFILLER_78_303 VGND VGND VPWR VPWR sky130_fd_sc_hd__decap_3
XFILLER_78_336 VGND VGND VPWR VPWR sky130_fd_sc_hd__decap_3
XFILLER_87_45 VGND VGND VPWR VPWR sky130_fd_sc_hd__decap_3
XFILLER_78_358 VGND VGND VPWR VPWR sky130_fd_sc_hd__decap_3
XFILLER_19_414 VGND VGND VPWR VPWR sky130_fd_sc_hd__fill_1
XFILLER_46_200 VGND VGND VPWR VPWR sky130_fd_sc_hd__decap_3
XFILLER_93_317 VGND VGND VPWR VPWR sky130_fd_sc_hd__fill_2
XFILLER_93_328 VGND VGND VPWR VPWR sky130_fd_sc_hd__fill_1
XFILLER_101_691 VGND VGND VPWR VPWR sky130_fd_sc_hd__fill_1
XFILLER_19_436 VGND VGND VPWR VPWR sky130_fd_sc_hd__fill_1
XFILLER_74_542 VGND VGND VPWR VPWR sky130_fd_sc_hd__fill_2
XFILLER_86_380 VGND VGND VPWR VPWR sky130_fd_sc_hd__decap_3
XFILLER_100_190 VGND VGND VPWR VPWR sky130_fd_sc_hd__decap_3
XFILLER_19_469 VGND VGND VPWR VPWR sky130_fd_sc_hd__fill_2
XFILLER_46_266 VGND VGND VPWR VPWR sky130_fd_sc_hd__fill_1
XFILLER_36_82 VGND VGND VPWR VPWR sky130_fd_sc_hd__fill_2
XFILLER_61_214 VGND VGND VPWR VPWR sky130_fd_sc_hd__decap_3
XFILLER_61_225 VGND VGND VPWR VPWR sky130_fd_sc_hd__decap_3
XFILLER_61_258 VGND VGND VPWR VPWR sky130_fd_sc_hd__decap_3
XFILLER_14_141 VGND VGND VPWR VPWR sky130_fd_sc_hd__decap_3
XFILLER_42_472 VGND VGND VPWR VPWR sky130_fd_sc_hd__decap_3
XFILLER_14_185 VGND VGND VPWR VPWR sky130_fd_sc_hd__decap_3
XFILLER_42_494 VGND VGND VPWR VPWR sky130_fd_sc_hd__fill_2
XFILLER_52_70 VGND VGND VPWR VPWR sky130_fd_sc_hd__decap_3
XFILLER_115_205 VGND VGND VPWR VPWR sky130_fd_sc_hd__decap_3
Xhold808 _6760_/Q VGND VGND VPWR VPWR _6760_/D sky130_fd_sc_hd__dlygate4sd3_1
Xhold819 _6925_/Q VGND VGND VPWR VPWR _6925_/D sky130_fd_sc_hd__dlygate4sd3_1
XTAP_TAPCELL_ROW_12_397 VGND VPWR sky130_fd_sc_hd__tapvpwrvgnd_1
XTAP_TAPCELL_ROW_116_1639 VGND VPWR sky130_fd_sc_hd__tapvpwrvgnd_1
XFILLER_6_384 VGND VGND VPWR VPWR sky130_fd_sc_hd__decap_3
X_3460_ _7313_/Q _3973_/S _4338_/B1 _7345_/Q _3556_/A VGND VGND VPWR VPWR _3460_/X
+ sky130_fd_sc_hd__a221o_2
X_3391_ _7251_/Q _3358_/X _3390_/X VGND VGND VPWR VPWR _3589_/A sky130_fd_sc_hd__a21oi_2
XFILLER_35_3 VGND VGND VPWR VPWR sky130_fd_sc_hd__decap_3
X_5130_ _5130_/A _5670_/B _5130_/C VGND VGND VPWR VPWR _6982_/D sky130_fd_sc_hd__nor3_2
XFILLER_111_455 VGND VGND VPWR VPWR sky130_fd_sc_hd__decap_3
XFILLER_69_358 VGND VGND VPWR VPWR sky130_fd_sc_hd__decap_3
XFILLER_96_144 VGND VGND VPWR VPWR sky130_fd_sc_hd__decap_3
X_5061_ _6988_/D _5060_/X _5156_/S VGND VGND VPWR VPWR _5061_/X sky130_fd_sc_hd__mux2_2
XFILLER_37_211 VGND VGND VPWR VPWR sky130_fd_sc_hd__decap_3
XFILLER_25_406 VGND VGND VPWR VPWR sky130_fd_sc_hd__decap_3
XFILLER_65_564 VGND VGND VPWR VPWR sky130_fd_sc_hd__decap_3
XFILLER_18_480 VGND VGND VPWR VPWR sky130_fd_sc_hd__decap_3
XFILLER_25_439 VGND VGND VPWR VPWR sky130_fd_sc_hd__decap_3
XFILLER_80_512 VGND VGND VPWR VPWR sky130_fd_sc_hd__decap_3
XFILLER_92_383 VGND VGND VPWR VPWR sky130_fd_sc_hd__fill_2
XFILLER_52_236 VGND VGND VPWR VPWR sky130_fd_sc_hd__decap_3
XFILLER_80_545 VGND VGND VPWR VPWR sky130_fd_sc_hd__decap_3
X_4914_ _4914_/A0 _4913_/X _5028_/S VGND VGND VPWR VPWR _7267_/D sky130_fd_sc_hd__mux2_2
XFILLER_20_100 VGND VGND VPWR VPWR sky130_fd_sc_hd__decap_3
XFILLER_21_634 VGND VGND VPWR VPWR sky130_fd_sc_hd__decap_3
XFILLER_32_29 VGND VGND VPWR VPWR sky130_fd_sc_hd__decap_3
XFILLER_33_483 VGND VGND VPWR VPWR sky130_fd_sc_hd__decap_3
X_4845_ _4845_/A VGND VGND VPWR VPWR _4872_/A sky130_fd_sc_hd__inv_2
XFILLER_20_144 VGND VGND VPWR VPWR sky130_fd_sc_hd__fill_1
X_4776_ _7004_/Q _4804_/A VGND VGND VPWR VPWR _4777_/C sky130_fd_sc_hd__or2_2
XFILLER_20_177 VGND VGND VPWR VPWR sky130_fd_sc_hd__decap_3
X_6515_ _6611_/A VGND VGND VPWR VPWR _6515_/Y sky130_fd_sc_hd__inv_2
X_3727_ _3746_/B _3733_/C VGND VGND VPWR VPWR _3728_/B sky130_fd_sc_hd__nand2_2
XFILLER_106_238 VGND VGND VPWR VPWR sky130_fd_sc_hd__fill_1
XFILLER_106_9 VGND VGND VPWR VPWR sky130_fd_sc_hd__decap_3
X_6446_ _6606_/A VGND VGND VPWR VPWR _6446_/Y sky130_fd_sc_hd__inv_2
XFILLER_88_601 VGND VGND VPWR VPWR sky130_fd_sc_hd__decap_3
X_6377_ _6539_/A VGND VGND VPWR VPWR _6377_/Y sky130_fd_sc_hd__inv_2
X_3589_ _3589_/A _3589_/B VGND VGND VPWR VPWR _3590_/B sky130_fd_sc_hd__nor2_2
XFILLER_0_527 VGND VGND VPWR VPWR sky130_fd_sc_hd__decap_3
XFILLER_0_549 VGND VGND VPWR VPWR sky130_fd_sc_hd__decap_3
XFILLER_102_433 VGND VGND VPWR VPWR sky130_fd_sc_hd__decap_3
XFILLER_57_15 VGND VGND VPWR VPWR sky130_fd_sc_hd__decap_3
XFILLER_88_645 VGND VGND VPWR VPWR sky130_fd_sc_hd__decap_3
XFILLER_88_678 VGND VGND VPWR VPWR sky130_fd_sc_hd__decap_3
XFILLER_102_477 VGND VGND VPWR VPWR sky130_fd_sc_hd__decap_3
XFILLER_57_48 VGND VGND VPWR VPWR sky130_fd_sc_hd__decap_3
XFILLER_87_177 VGND VGND VPWR VPWR sky130_fd_sc_hd__decap_3
XFILLER_113_21 VGND VGND VPWR VPWR sky130_fd_sc_hd__decap_3
XFILLER_28_200 VGND VGND VPWR VPWR sky130_fd_sc_hd__decap_3
XFILLER_68_380 VGND VGND VPWR VPWR sky130_fd_sc_hd__decap_3
XFILLER_113_54 VGND VGND VPWR VPWR sky130_fd_sc_hd__fill_2
XFILLER_71_501 VGND VGND VPWR VPWR sky130_fd_sc_hd__decap_3
XFILLER_90_309 VGND VGND VPWR VPWR sky130_fd_sc_hd__fill_2
XFILLER_113_87 VGND VGND VPWR VPWR sky130_fd_sc_hd__decap_3
XFILLER_28_288 VGND VGND VPWR VPWR sky130_fd_sc_hd__decap_3
XFILLER_43_225 VGND VGND VPWR VPWR sky130_fd_sc_hd__fill_2
XFILLER_56_597 VGND VGND VPWR VPWR sky130_fd_sc_hd__decap_3
XFILLER_73_36 VGND VGND VPWR VPWR sky130_fd_sc_hd__decap_3
XFILLER_12_612 VGND VGND VPWR VPWR sky130_fd_sc_hd__fill_1
XFILLER_24_472 VGND VGND VPWR VPWR sky130_fd_sc_hd__decap_3
XFILLER_11_111 VGND VGND VPWR VPWR sky130_fd_sc_hd__fill_1
XFILLER_11_122 VGND VGND VPWR VPWR sky130_fd_sc_hd__decap_3
XFILLER_12_689 VGND VGND VPWR VPWR sky130_fd_sc_hd__decap_3
XFILLER_8_616 VGND VGND VPWR VPWR sky130_fd_sc_hd__decap_3
XFILLER_7_137 VGND VGND VPWR VPWR sky130_fd_sc_hd__decap_3
XFILLER_22_62 VGND VGND VPWR VPWR sky130_fd_sc_hd__decap_3
XFILLER_3_321 VGND VGND VPWR VPWR sky130_fd_sc_hd__decap_3
XFILLER_98_66 VGND VGND VPWR VPWR sky130_fd_sc_hd__decap_3
XFILLER_3_387 VGND VGND VPWR VPWR sky130_fd_sc_hd__decap_3
XFILLER_78_111 VGND VGND VPWR VPWR sky130_fd_sc_hd__decap_3
XFILLER_98_99 VGND VGND VPWR VPWR sky130_fd_sc_hd__decap_3
XFILLER_79_667 VGND VGND VPWR VPWR sky130_fd_sc_hd__decap_3
XFILLER_21_9 VGND VGND VPWR VPWR sky130_fd_sc_hd__decap_3
XFILLER_78_166 VGND VGND VPWR VPWR sky130_fd_sc_hd__decap_3
XFILLER_93_103 VGND VGND VPWR VPWR sky130_fd_sc_hd__decap_3
XFILLER_94_626 VGND VGND VPWR VPWR sky130_fd_sc_hd__decap_3
XFILLER_19_222 VGND VGND VPWR VPWR sky130_fd_sc_hd__fill_2
XFILLER_66_328 VGND VGND VPWR VPWR sky130_fd_sc_hd__decap_3
XFILLER_93_125 VGND VGND VPWR VPWR sky130_fd_sc_hd__decap_3
XFILLER_94_648 VGND VGND VPWR VPWR sky130_fd_sc_hd__decap_3
XFILLER_47_81 VGND VGND VPWR VPWR sky130_fd_sc_hd__decap_3
XFILLER_19_277 VGND VGND VPWR VPWR sky130_fd_sc_hd__decap_3
XFILLER_34_203 VGND VGND VPWR VPWR sky130_fd_sc_hd__decap_3
XFILLER_47_586 VGND VGND VPWR VPWR sky130_fd_sc_hd__decap_3
XFILLER_74_383 VGND VGND VPWR VPWR sky130_fd_sc_hd__decap_3
XFILLER_34_236 VGND VGND VPWR VPWR sky130_fd_sc_hd__decap_3
XTAP_TAPCELL_ROW_66_1048 VGND VPWR sky130_fd_sc_hd__tapvpwrvgnd_1
XTAP_TAPCELL_ROW_45_787 VGND VPWR sky130_fd_sc_hd__tapvpwrvgnd_1
XTAP_TAPCELL_ROW_17_456 VGND VPWR sky130_fd_sc_hd__tapvpwrvgnd_1
XFILLER_30_453 VGND VGND VPWR VPWR sky130_fd_sc_hd__decap_3
XFILLER_8_20 VGND VGND VPWR VPWR sky130_fd_sc_hd__decap_3
X_4630_ _4627_/Y _4629_/Y _4372_/A VGND VGND VPWR VPWR _4630_/X sky130_fd_sc_hd__a21o_2
XFILLER_8_53 VGND VGND VPWR VPWR sky130_fd_sc_hd__decap_3
XFILLER_8_97 VGND VGND VPWR VPWR sky130_fd_sc_hd__decap_3
X_6300_ _6366_/A VGND VGND VPWR VPWR _6300_/Y sky130_fd_sc_hd__inv_2
X_4561_ _4561_/A _4561_/B VGND VGND VPWR VPWR _7300_/D sky130_fd_sc_hd__and2_2
XFILLER_116_525 VGND VGND VPWR VPWR sky130_fd_sc_hd__decap_3
XFILLER_7_671 VGND VGND VPWR VPWR sky130_fd_sc_hd__fill_1
XFILLER_7_682 VGND VGND VPWR VPWR sky130_fd_sc_hd__decap_3
X_7280_ _7322_/CLK _7280_/D _6560_/Y VGND VGND VPWR VPWR _7280_/Q sky130_fd_sc_hd__dfrtp_2
Xhold605 _6933_/Q VGND VGND VPWR VPWR _6933_/D sky130_fd_sc_hd__dlygate4sd3_1
Xhold616 _6918_/Q VGND VGND VPWR VPWR _6918_/D sky130_fd_sc_hd__dlygate4sd3_1
Xhold627 _6895_/Q VGND VGND VPWR VPWR _6895_/D sky130_fd_sc_hd__dlygate4sd3_1
Xhold638 _6743_/Q VGND VGND VPWR VPWR _6743_/D sky130_fd_sc_hd__dlygate4sd3_1
Xhold649 _6927_/Q VGND VGND VPWR VPWR _6927_/D sky130_fd_sc_hd__dlygate4sd3_1
XTAP_TAPCELL_ROW_77_1177 VGND VPWR sky130_fd_sc_hd__tapvpwrvgnd_1
XTAP_TAPCELL_ROW_90_1333 VGND VPWR sky130_fd_sc_hd__tapvpwrvgnd_1
X_5113_ _5113_/A _5113_/B VGND VGND VPWR VPWR _5113_/Y sky130_fd_sc_hd__xnor2_2
XFILLER_69_155 VGND VGND VPWR VPWR sky130_fd_sc_hd__decap_3
XFILLER_69_199 VGND VGND VPWR VPWR sky130_fd_sc_hd__decap_3
XFILLER_85_637 VGND VGND VPWR VPWR sky130_fd_sc_hd__decap_3
X_5044_ _5044_/A _5044_/B VGND VGND VPWR VPWR _6988_/D sky130_fd_sc_hd__nor2_2
XFILLER_38_564 VGND VGND VPWR VPWR sky130_fd_sc_hd__fill_1
XFILLER_72_309 VGND VGND VPWR VPWR sky130_fd_sc_hd__decap_3
XFILLER_84_147 VGND VGND VPWR VPWR sky130_fd_sc_hd__decap_3
XFILLER_25_203 VGND VGND VPWR VPWR sky130_fd_sc_hd__fill_2
XFILLER_65_361 VGND VGND VPWR VPWR sky130_fd_sc_hd__fill_2
XFILLER_25_236 VGND VGND VPWR VPWR sky130_fd_sc_hd__decap_3
XFILLER_80_320 VGND VGND VPWR VPWR sky130_fd_sc_hd__decap_3
X_6995_ _7403_/CLK _6995_/D _6275_/Y VGND VGND VPWR VPWR _6995_/Q sky130_fd_sc_hd__dfrtp_2
XFILLER_43_17 VGND VGND VPWR VPWR sky130_fd_sc_hd__decap_3
XFILLER_53_589 VGND VGND VPWR VPWR sky130_fd_sc_hd__decap_3
XFILLER_43_39 VGND VGND VPWR VPWR sky130_fd_sc_hd__decap_3
X_4828_ _3526_/B _4810_/B _4827_/A _5033_/B2 VGND VGND VPWR VPWR _4828_/X sky130_fd_sc_hd__a22o_2
XFILLER_5_608 VGND VGND VPWR VPWR sky130_fd_sc_hd__decap_3
X_4759_ _4759_/A _4777_/B VGND VGND VPWR VPWR _4760_/B sky130_fd_sc_hd__xnor2_2
XFILLER_4_118 VGND VGND VPWR VPWR sky130_fd_sc_hd__decap_3
XFILLER_104_6 VGND VGND VPWR VPWR sky130_fd_sc_hd__decap_3
XFILLER_108_21 VGND VGND VPWR VPWR sky130_fd_sc_hd__decap_3
XFILLER_108_32 VGND VGND VPWR VPWR sky130_fd_sc_hd__decap_3
X_6429_ _6647_/A VGND VGND VPWR VPWR _6429_/Y sky130_fd_sc_hd__inv_2
XFILLER_108_65 VGND VGND VPWR VPWR sky130_fd_sc_hd__decap_3
XFILLER_68_14 VGND VGND VPWR VPWR sky130_fd_sc_hd__decap_3
XFILLER_0_335 VGND VGND VPWR VPWR sky130_fd_sc_hd__fill_1
XFILLER_115_591 VGND VGND VPWR VPWR sky130_fd_sc_hd__decap_3
XFILLER_68_69 VGND VGND VPWR VPWR sky130_fd_sc_hd__decap_3
XFILLER_88_442 VGND VGND VPWR VPWR sky130_fd_sc_hd__decap_3
XFILLER_0_357 VGND VGND VPWR VPWR sky130_fd_sc_hd__fill_2
XFILLER_0_368 VGND VGND VPWR VPWR sky130_fd_sc_hd__decap_3
XFILLER_102_241 VGND VGND VPWR VPWR sky130_fd_sc_hd__decap_3
XFILLER_48_306 VGND VGND VPWR VPWR sky130_fd_sc_hd__fill_2
XFILLER_29_531 VGND VGND VPWR VPWR sky130_fd_sc_hd__decap_3
XFILLER_48_328 VGND VGND VPWR VPWR sky130_fd_sc_hd__decap_3
XFILLER_75_125 VGND VGND VPWR VPWR sky130_fd_sc_hd__decap_3
XFILLER_76_637 VGND VGND VPWR VPWR sky130_fd_sc_hd__decap_3
XFILLER_76_648 VGND VGND VPWR VPWR sky130_fd_sc_hd__fill_1
XFILLER_75_169 VGND VGND VPWR VPWR sky130_fd_sc_hd__decap_3
XFILLER_84_35 VGND VGND VPWR VPWR sky130_fd_sc_hd__decap_3
XFILLER_16_203 VGND VGND VPWR VPWR sky130_fd_sc_hd__decap_3
XFILLER_56_361 VGND VGND VPWR VPWR sky130_fd_sc_hd__decap_3
XFILLER_84_68 VGND VGND VPWR VPWR sky130_fd_sc_hd__decap_3
XFILLER_90_106 VGND VGND VPWR VPWR sky130_fd_sc_hd__decap_3
Xplace309 _3522_/Y VGND VGND VPWR VPWR _5020_/A sky130_fd_sc_hd__buf_2
XFILLER_16_236 VGND VGND VPWR VPWR sky130_fd_sc_hd__decap_3
XFILLER_17_51 VGND VGND VPWR VPWR sky130_fd_sc_hd__decap_3
XFILLER_17_84 VGND VGND VPWR VPWR sky130_fd_sc_hd__decap_3
XFILLER_44_578 VGND VGND VPWR VPWR sky130_fd_sc_hd__fill_2
XFILLER_44_589 VGND VGND VPWR VPWR sky130_fd_sc_hd__decap_3
XFILLER_24_280 VGND VGND VPWR VPWR sky130_fd_sc_hd__decap_3
XTAP_TAPCELL_ROW_14_415 VGND VPWR sky130_fd_sc_hd__tapvpwrvgnd_1
XFILLER_12_431 VGND VGND VPWR VPWR sky130_fd_sc_hd__decap_3
XFILLER_8_402 VGND VGND VPWR VPWR sky130_fd_sc_hd__decap_3
XTAP_TAPCELL_ROW_42_757 VGND VPWR sky130_fd_sc_hd__tapvpwrvgnd_1
XFILLER_8_446 VGND VGND VPWR VPWR sky130_fd_sc_hd__decap_3
XFILLER_69_9 VGND VGND VPWR VPWR sky130_fd_sc_hd__decap_3
XFILLER_4_641 VGND VGND VPWR VPWR sky130_fd_sc_hd__decap_3
XTAP_TAPCELL_ROW_113_1609 VGND VPWR sky130_fd_sc_hd__tapvpwrvgnd_1
XFILLER_3_140 VGND VGND VPWR VPWR sky130_fd_sc_hd__decap_3
XFILLER_4_663 VGND VGND VPWR VPWR sky130_fd_sc_hd__decap_3
XFILLER_79_420 VGND VGND VPWR VPWR sky130_fd_sc_hd__decap_3
XFILLER_67_604 VGND VGND VPWR VPWR sky130_fd_sc_hd__decap_3
XFILLER_58_91 VGND VGND VPWR VPWR sky130_fd_sc_hd__decap_3
XFILLER_66_114 VGND VGND VPWR VPWR sky130_fd_sc_hd__decap_3
XFILLER_82_607 VGND VGND VPWR VPWR sky130_fd_sc_hd__decap_3
XFILLER_47_372 VGND VGND VPWR VPWR sky130_fd_sc_hd__decap_3
XFILLER_81_128 VGND VGND VPWR VPWR sky130_fd_sc_hd__decap_3
XFILLER_62_320 VGND VGND VPWR VPWR sky130_fd_sc_hd__fill_2
XFILLER_74_180 VGND VGND VPWR VPWR sky130_fd_sc_hd__fill_2
XFILLER_22_206 VGND VGND VPWR VPWR sky130_fd_sc_hd__decap_3
XFILLER_35_589 VGND VGND VPWR VPWR sky130_fd_sc_hd__decap_3
XFILLER_90_673 VGND VGND VPWR VPWR sky130_fd_sc_hd__decap_3
X_6780_ _7387_/CLK _6780_/D VGND VGND VPWR VPWR _6780_/Q sky130_fd_sc_hd__dfxtp_2
X_3992_ _5156_/S _5587_/B VGND VGND VPWR VPWR _3992_/Y sky130_fd_sc_hd__nand2_2
XFILLER_22_239 VGND VGND VPWR VPWR sky130_fd_sc_hd__decap_3
XFILLER_62_397 VGND VGND VPWR VPWR sky130_fd_sc_hd__decap_3
X_5731_ _7371_/Q hold916/X _5737_/S VGND VGND VPWR VPWR _6715_/D sky130_fd_sc_hd__mux2_2
X_5662_ _5662_/A _5662_/B _5662_/C _5661_/X VGND VGND VPWR VPWR _5663_/D sky130_fd_sc_hd__or4b_4
X_7401_ _7401_/CLK _7401_/D _6681_/Y VGND VGND VPWR VPWR _7401_/Q sky130_fd_sc_hd__dfrtp_2
X_5593_ _5593_/A _5595_/B VGND VGND VPWR VPWR _7031_/D sky130_fd_sc_hd__or2_2
X_4613_ _4614_/B _4613_/B _5113_/A VGND VGND VPWR VPWR _4617_/B sky130_fd_sc_hd__and3_2
X_7332_ _7365_/CLK _7332_/D _6612_/Y VGND VGND VPWR VPWR _7332_/Q sky130_fd_sc_hd__dfrtp_2
X_4544_ _4544_/A _4561_/B VGND VGND VPWR VPWR _7308_/D sky130_fd_sc_hd__and2_2
X_7263_ _7264_/CLK _7263_/D _6543_/Y VGND VGND VPWR VPWR _7263_/Q sky130_fd_sc_hd__dfrtp_2
XFILLER_104_506 VGND VGND VPWR VPWR sky130_fd_sc_hd__decap_3
XFILLER_104_517 VGND VGND VPWR VPWR sky130_fd_sc_hd__decap_3
XFILLER_116_388 VGND VGND VPWR VPWR sky130_fd_sc_hd__decap_3
XFILLER_89_217 VGND VGND VPWR VPWR sky130_fd_sc_hd__decap_3
XFILLER_89_228 VGND VGND VPWR VPWR sky130_fd_sc_hd__fill_2
XFILLER_116_399 VGND VGND VPWR VPWR sky130_fd_sc_hd__decap_3
X_7194_ _7386_/CLK _7194_/D _6474_/Y VGND VGND VPWR VPWR _7194_/Q sky130_fd_sc_hd__dfrtp_2
X_3426_ _3589_/A _3591_/A _3589_/B _3590_/C VGND VGND VPWR VPWR _3427_/B sky130_fd_sc_hd__or4_4
XFILLER_58_615 VGND VGND VPWR VPWR sky130_fd_sc_hd__decap_3
XFILLER_97_261 VGND VGND VPWR VPWR sky130_fd_sc_hd__decap_3
X_3357_ _4537_/B VGND VGND VPWR VPWR _3449_/A sky130_fd_sc_hd__inv_6
XFILLER_58_648 VGND VGND VPWR VPWR sky130_fd_sc_hd__decap_3
XFILLER_85_423 VGND VGND VPWR VPWR sky130_fd_sc_hd__decap_3
Xhold1102 _7321_/Q VGND VGND VPWR VPWR _4517_/A0 sky130_fd_sc_hd__dlygate4sd3_1
Xhold1113 _7245_/Q VGND VGND VPWR VPWR _5165_/A sky130_fd_sc_hd__dlygate4sd3_1
Xhold1124 _7224_/Q VGND VGND VPWR VPWR _5209_/A sky130_fd_sc_hd__dlygate4sd3_1
XFILLER_57_147 VGND VGND VPWR VPWR sky130_fd_sc_hd__decap_3
Xhold1135 _7216_/Q VGND VGND VPWR VPWR _5225_/A sky130_fd_sc_hd__dlygate4sd3_1
Xhold1146 _7173_/Q VGND VGND VPWR VPWR _5315_/A0 sky130_fd_sc_hd__dlygate4sd3_1
Xhold1157 _7131_/Q VGND VGND VPWR VPWR _5404_/A0 sky130_fd_sc_hd__dlygate4sd3_1
X_5027_ _5092_/C _5024_/X _6990_/D _5666_/A VGND VGND VPWR VPWR _5027_/X sky130_fd_sc_hd__a22o_2
XFILLER_66_681 VGND VGND VPWR VPWR sky130_fd_sc_hd__decap_3
XFILLER_73_629 VGND VGND VPWR VPWR sky130_fd_sc_hd__decap_3
Xhold1168 _7142_/Q VGND VGND VPWR VPWR _5381_/A0 sky130_fd_sc_hd__dlygate4sd3_1
Xhold1179 _7396_/Q VGND VGND VPWR VPWR _3757_/A0 sky130_fd_sc_hd__dlygate4sd3_1
XFILLER_26_556 VGND VGND VPWR VPWR sky130_fd_sc_hd__decap_3
XFILLER_38_383 VGND VGND VPWR VPWR sky130_fd_sc_hd__decap_3
XFILLER_54_27 VGND VGND VPWR VPWR sky130_fd_sc_hd__fill_1
XFILLER_54_38 VGND VGND VPWR VPWR sky130_fd_sc_hd__decap_3
XFILLER_26_589 VGND VGND VPWR VPWR sky130_fd_sc_hd__decap_3
XFILLER_80_150 VGND VGND VPWR VPWR sky130_fd_sc_hd__decap_3
XFILLER_81_673 VGND VGND VPWR VPWR sky130_fd_sc_hd__decap_3
XFILLER_110_44 VGND VGND VPWR VPWR sky130_fd_sc_hd__decap_3
XFILLER_13_217 VGND VGND VPWR VPWR sky130_fd_sc_hd__decap_3
XFILLER_41_526 VGND VGND VPWR VPWR sky130_fd_sc_hd__decap_3
XFILLER_80_183 VGND VGND VPWR VPWR sky130_fd_sc_hd__decap_3
X_6978_ _6978_/CLK _6978_/D VGND VGND VPWR VPWR _6978_/Q sky130_fd_sc_hd__dfxtp_2
XFILLER_110_77 VGND VGND VPWR VPWR sky130_fd_sc_hd__decap_3
XFILLER_70_15 VGND VGND VPWR VPWR sky130_fd_sc_hd__decap_3
XFILLER_110_88 VGND VGND VPWR VPWR sky130_fd_sc_hd__decap_3
XFILLER_107_322 VGND VGND VPWR VPWR sky130_fd_sc_hd__decap_3
XFILLER_5_416 VGND VGND VPWR VPWR sky130_fd_sc_hd__decap_3
XFILLER_102_3 VGND VGND VPWR VPWR sky130_fd_sc_hd__decap_3
XFILLER_107_377 VGND VGND VPWR VPWR sky130_fd_sc_hd__decap_3
XFILLER_79_57 VGND VGND VPWR VPWR sky130_fd_sc_hd__decap_3
XFILLER_0_110 VGND VGND VPWR VPWR sky130_fd_sc_hd__fill_2
XFILLER_1_644 VGND VGND VPWR VPWR sky130_fd_sc_hd__decap_3
Xhold991 _7013_/Q VGND VGND VPWR VPWR _5630_/A sky130_fd_sc_hd__dlygate4sd3_1
Xhold980 _7387_/Q VGND VGND VPWR VPWR hold980/X sky130_fd_sc_hd__dlygate4sd3_1
XFILLER_0_132 VGND VGND VPWR VPWR sky130_fd_sc_hd__decap_3
XFILLER_103_561 VGND VGND VPWR VPWR sky130_fd_sc_hd__decap_3
XFILLER_76_401 VGND VGND VPWR VPWR sky130_fd_sc_hd__decap_3
XFILLER_95_12 VGND VGND VPWR VPWR sky130_fd_sc_hd__decap_3
XFILLER_0_165 VGND VGND VPWR VPWR sky130_fd_sc_hd__decap_3
XFILLER_49_626 VGND VGND VPWR VPWR sky130_fd_sc_hd__decap_3
XFILLER_36_309 VGND VGND VPWR VPWR sky130_fd_sc_hd__decap_3
XFILLER_49_659 VGND VGND VPWR VPWR sky130_fd_sc_hd__decap_3
XFILLER_91_426 VGND VGND VPWR VPWR sky130_fd_sc_hd__decap_3
XTAP_TAPCELL_ROW_47_816 VGND VPWR sky130_fd_sc_hd__tapvpwrvgnd_1
XFILLER_28_94 VGND VGND VPWR VPWR sky130_fd_sc_hd__decap_3
XFILLER_32_515 VGND VGND VPWR VPWR sky130_fd_sc_hd__decap_3
XFILLER_44_342 VGND VGND VPWR VPWR sky130_fd_sc_hd__decap_3
XFILLER_72_684 VGND VGND VPWR VPWR sky130_fd_sc_hd__decap_3
XTAP_TAPCELL_ROW_63_1007 VGND VPWR sky130_fd_sc_hd__tapvpwrvgnd_1
XTAP_TAPCELL_ROW_27_573 VGND VPWR sky130_fd_sc_hd__tapvpwrvgnd_1
XFILLER_12_250 VGND VGND VPWR VPWR sky130_fd_sc_hd__fill_2
XFILLER_12_283 VGND VGND VPWR VPWR sky130_fd_sc_hd__decap_3
XFILLER_67_6 VGND VGND VPWR VPWR sky130_fd_sc_hd__decap_3
XFILLER_5_21 VGND VGND VPWR VPWR sky130_fd_sc_hd__decap_3
Xoutput518 _5362_/C VGND VGND VPWR VPWR instruction_out[8] sky130_fd_sc_hd__clkdlybuf4s25_1
Xoutput507 _3562_/B VGND VGND VPWR VPWR instruction_out[25] sky130_fd_sc_hd__clkdlybuf4s25_1
XFILLER_113_314 VGND VGND VPWR VPWR sky130_fd_sc_hd__decap_3
XFILLER_5_54 VGND VGND VPWR VPWR sky130_fd_sc_hd__fill_2
Xoutput529 _6995_/Q VGND VGND VPWR VPWR pc_out[18] sky130_fd_sc_hd__clkdlybuf4s25_1
XTAP_TAPCELL_ROW_74_1136 VGND VPWR sky130_fd_sc_hd__tapvpwrvgnd_1
XFILLER_99_537 VGND VGND VPWR VPWR sky130_fd_sc_hd__decap_3
XFILLER_113_325 VGND VGND VPWR VPWR sky130_fd_sc_hd__decap_3
XFILLER_5_87 VGND VGND VPWR VPWR sky130_fd_sc_hd__decap_3
X_4260_ _7262_/Q _4356_/A2 _3968_/S _7326_/Q VGND VGND VPWR VPWR _4264_/A sky130_fd_sc_hd__a22o_2
XFILLER_79_250 VGND VGND VPWR VPWR sky130_fd_sc_hd__fill_1
X_4191_ _7071_/Q _4265_/B _4205_/A VGND VGND VPWR VPWR _4637_/C sky130_fd_sc_hd__o21a_2
XFILLER_39_125 VGND VGND VPWR VPWR sky130_fd_sc_hd__decap_3
XFILLER_94_253 VGND VGND VPWR VPWR sky130_fd_sc_hd__decap_3
XFILLER_48_681 VGND VGND VPWR VPWR sky130_fd_sc_hd__decap_3
XFILLER_55_629 VGND VGND VPWR VPWR sky130_fd_sc_hd__decap_3
XFILLER_82_404 VGND VGND VPWR VPWR sky130_fd_sc_hd__decap_3
XFILLER_94_286 VGND VGND VPWR VPWR sky130_fd_sc_hd__decap_3
XFILLER_47_191 VGND VGND VPWR VPWR sky130_fd_sc_hd__decap_3
X_6901_ _6978_/CLK _6901_/D VGND VGND VPWR VPWR _6901_/Q sky130_fd_sc_hd__dfxtp_2
XFILLER_35_353 VGND VGND VPWR VPWR sky130_fd_sc_hd__decap_3
XFILLER_62_150 VGND VGND VPWR VPWR sky130_fd_sc_hd__decap_3
XFILLER_63_662 VGND VGND VPWR VPWR sky130_fd_sc_hd__decap_3
XFILLER_63_673 VGND VGND VPWR VPWR sky130_fd_sc_hd__decap_3
X_6832_ _6972_/CLK _6832_/D VGND VGND VPWR VPWR _6832_/Q sky130_fd_sc_hd__dfxtp_2
XFILLER_23_526 VGND VGND VPWR VPWR sky130_fd_sc_hd__decap_3
XFILLER_50_323 VGND VGND VPWR VPWR sky130_fd_sc_hd__fill_1
XFILLER_62_172 VGND VGND VPWR VPWR sky130_fd_sc_hd__decap_3
XFILLER_90_492 VGND VGND VPWR VPWR sky130_fd_sc_hd__fill_1
XTAP_TAPCELL_ROW_85_1276 VGND VPWR sky130_fd_sc_hd__tapvpwrvgnd_1
XFILLER_50_345 VGND VGND VPWR VPWR sky130_fd_sc_hd__decap_3
X_6763_ _6966_/CLK _6763_/D VGND VGND VPWR VPWR _6763_/Q sky130_fd_sc_hd__dfxtp_2
X_3975_ _7353_/Q _4517_/A0 _4471_/S VGND VGND VPWR VPWR _7353_/D sky130_fd_sc_hd__mux2_2
XFILLER_31_581 VGND VGND VPWR VPWR sky130_fd_sc_hd__fill_1
X_6694_ clkload4/A _6694_/D VGND VGND VPWR VPWR _6694_/Q sky130_fd_sc_hd__dfxtp_2
X_5645_ _5129_/A _3403_/A _3519_/B _5644_/X VGND VGND VPWR VPWR _5645_/X sky130_fd_sc_hd__o31a_2
XFILLER_40_29 VGND VGND VPWR VPWR sky130_fd_sc_hd__decap_3
X_5576_ hold944/X _4960_/A _5015_/X VGND VGND VPWR VPWR _7041_/D sky130_fd_sc_hd__a21o_2
XFILLER_116_141 VGND VGND VPWR VPWR sky130_fd_sc_hd__decap_3
XFILLER_2_419 VGND VGND VPWR VPWR sky130_fd_sc_hd__fill_1
X_7315_ clkload5/A _7315_/D _6595_/Y VGND VGND VPWR VPWR _7315_/Q sky130_fd_sc_hd__dfrtp_2
X_7246_ _7374_/CLK _7246_/D _6526_/Y VGND VGND VPWR VPWR _7246_/Q sky130_fd_sc_hd__dfrtp_2
X_4458_ _4458_/A _4039_/A VGND VGND VPWR VPWR _4458_/X sky130_fd_sc_hd__or2b_2
XFILLER_49_49 VGND VGND VPWR VPWR sky130_fd_sc_hd__decap_3
XFILLER_77_209 VGND VGND VPWR VPWR sky130_fd_sc_hd__decap_3
X_7177_ _7403_/CLK _7177_/D _6457_/Y VGND VGND VPWR VPWR _7177_/Q sky130_fd_sc_hd__dfrtp_2
X_3409_ _3449_/A _3449_/B _3421_/C _3409_/D VGND VGND VPWR VPWR _3409_/X sky130_fd_sc_hd__and4_2
XFILLER_105_33 VGND VGND VPWR VPWR sky130_fd_sc_hd__decap_3
X_4389_ _7081_/Q _4432_/A2 _4205_/A _4388_/X VGND VGND VPWR VPWR _4396_/A sky130_fd_sc_hd__o211ai_2
XFILLER_98_570 VGND VGND VPWR VPWR sky130_fd_sc_hd__fill_1
XFILLER_100_531 VGND VGND VPWR VPWR sky130_fd_sc_hd__fill_1
XFILLER_58_445 VGND VGND VPWR VPWR sky130_fd_sc_hd__decap_3
XFILLER_65_15 VGND VGND VPWR VPWR sky130_fd_sc_hd__decap_3
XFILLER_100_586 VGND VGND VPWR VPWR sky130_fd_sc_hd__fill_2
XFILLER_18_309 VGND VGND VPWR VPWR sky130_fd_sc_hd__decap_3
XFILLER_46_618 VGND VGND VPWR VPWR sky130_fd_sc_hd__decap_3
XFILLER_85_264 VGND VGND VPWR VPWR sky130_fd_sc_hd__decap_3
XFILLER_38_180 VGND VGND VPWR VPWR sky130_fd_sc_hd__decap_3
XFILLER_54_640 VGND VGND VPWR VPWR sky130_fd_sc_hd__decap_3
XFILLER_26_342 VGND VGND VPWR VPWR sky130_fd_sc_hd__fill_1
XFILLER_54_651 VGND VGND VPWR VPWR sky130_fd_sc_hd__decap_3
XFILLER_14_548 VGND VGND VPWR VPWR sky130_fd_sc_hd__decap_3
XFILLER_41_323 VGND VGND VPWR VPWR sky130_fd_sc_hd__decap_3
XFILLER_53_172 VGND VGND VPWR VPWR sky130_fd_sc_hd__decap_3
XFILLER_54_684 VGND VGND VPWR VPWR sky130_fd_sc_hd__decap_3
XFILLER_81_36 VGND VGND VPWR VPWR sky130_fd_sc_hd__decap_3
XFILLER_81_470 VGND VGND VPWR VPWR sky130_fd_sc_hd__decap_3
XFILLER_41_367 VGND VGND VPWR VPWR sky130_fd_sc_hd__fill_1
XFILLER_81_69 VGND VGND VPWR VPWR sky130_fd_sc_hd__fill_1
XTAP_TAPCELL_ROW_24_543 VGND VPWR sky130_fd_sc_hd__tapvpwrvgnd_1
XFILLER_14_41 VGND VGND VPWR VPWR sky130_fd_sc_hd__decap_3
XTAP_TAPCELL_ROW_52_874 VGND VPWR sky130_fd_sc_hd__tapvpwrvgnd_1
XFILLER_108_631 VGND VGND VPWR VPWR sky130_fd_sc_hd__decap_3
XFILLER_108_675 VGND VGND VPWR VPWR sky130_fd_sc_hd__decap_3
XFILLER_107_196 VGND VGND VPWR VPWR sky130_fd_sc_hd__decap_3
XFILLER_110_306 VGND VGND VPWR VPWR sky130_fd_sc_hd__fill_2
XFILLER_1_452 VGND VGND VPWR VPWR sky130_fd_sc_hd__decap_3
XFILLER_110_317 VGND VGND VPWR VPWR sky130_fd_sc_hd__decap_3
XFILLER_103_380 VGND VGND VPWR VPWR sky130_fd_sc_hd__decap_3
XFILLER_36_117 VGND VGND VPWR VPWR sky130_fd_sc_hd__fill_1
XFILLER_64_404 VGND VGND VPWR VPWR sky130_fd_sc_hd__decap_3
XFILLER_76_253 VGND VGND VPWR VPWR sky130_fd_sc_hd__decap_3
XFILLER_17_364 VGND VGND VPWR VPWR sky130_fd_sc_hd__decap_3
XFILLER_45_662 VGND VGND VPWR VPWR sky130_fd_sc_hd__decap_3
XFILLER_45_673 VGND VGND VPWR VPWR sky130_fd_sc_hd__decap_3
XFILLER_51_109 VGND VGND VPWR VPWR sky130_fd_sc_hd__decap_3
XFILLER_55_81 VGND VGND VPWR VPWR sky130_fd_sc_hd__decap_3
XFILLER_91_267 VGND VGND VPWR VPWR sky130_fd_sc_hd__decap_3
XFILLER_32_323 VGND VGND VPWR VPWR sky130_fd_sc_hd__fill_2
XFILLER_60_610 VGND VGND VPWR VPWR sky130_fd_sc_hd__decap_3
XFILLER_44_194 VGND VGND VPWR VPWR sky130_fd_sc_hd__fill_2
XFILLER_60_643 VGND VGND VPWR VPWR sky130_fd_sc_hd__fill_1
XFILLER_60_654 VGND VGND VPWR VPWR sky130_fd_sc_hd__decap_3
XFILLER_60_687 VGND VGND VPWR VPWR sky130_fd_sc_hd__decap_3
X_3760_ _6933_/Q _3902_/A2 _3767_/A2 _6707_/Q VGND VGND VPWR VPWR _3760_/X sky130_fd_sc_hd__a22o_2
X_3691_ _6941_/Q _3902_/A2 _3759_/A2 _6805_/Q VGND VGND VPWR VPWR _3691_/X sky130_fd_sc_hd__a22o_2
XFILLER_65_3 VGND VGND VPWR VPWR sky130_fd_sc_hd__decap_3
XFILLER_114_601 VGND VGND VPWR VPWR sky130_fd_sc_hd__decap_3
XFILLER_113_111 VGND VGND VPWR VPWR sky130_fd_sc_hd__fill_1
XFILLER_113_122 VGND VGND VPWR VPWR sky130_fd_sc_hd__decap_3
XFILLER_114_634 VGND VGND VPWR VPWR sky130_fd_sc_hd__decap_3
XFILLER_114_645 VGND VGND VPWR VPWR sky130_fd_sc_hd__decap_3
X_7100_ clkload9/A _7100_/D _6380_/Y VGND VGND VPWR VPWR _7100_/Q sky130_fd_sc_hd__dfrtp_2
X_5292_ _5292_/A0 _4470_/X _5292_/S VGND VGND VPWR VPWR _7183_/D sky130_fd_sc_hd__mux2_2
X_4312_ _4394_/A _4337_/B _4311_/X VGND VGND VPWR VPWR _4313_/D sky130_fd_sc_hd__or3b_2
XFILLER_99_345 VGND VGND VPWR VPWR sky130_fd_sc_hd__decap_3
XFILLER_99_323 VGND VGND VPWR VPWR sky130_fd_sc_hd__decap_3
XFILLER_113_155 VGND VGND VPWR VPWR sky130_fd_sc_hd__decap_3
XFILLER_114_678 VGND VGND VPWR VPWR sky130_fd_sc_hd__decap_3
X_7031_ clkload4/A _7031_/D _6311_/Y VGND VGND VPWR VPWR _7031_/Q sky130_fd_sc_hd__dfrtp_2
X_4243_ _4620_/A _5032_/A VGND VGND VPWR VPWR _4243_/Y sky130_fd_sc_hd__nor2_2
XFILLER_99_378 VGND VGND VPWR VPWR sky130_fd_sc_hd__decap_3
XFILLER_101_317 VGND VGND VPWR VPWR sky130_fd_sc_hd__decap_3
XFILLER_113_199 VGND VGND VPWR VPWR sky130_fd_sc_hd__decap_3
XFILLER_87_529 VGND VGND VPWR VPWR sky130_fd_sc_hd__decap_3
XFILLER_67_231 VGND VGND VPWR VPWR sky130_fd_sc_hd__fill_1
X_4174_ _7296_/Q _4503_/S _4354_/B1 _7360_/Q VGND VGND VPWR VPWR _4174_/X sky130_fd_sc_hd__a22o_2
XFILLER_67_253 VGND VGND VPWR VPWR sky130_fd_sc_hd__decap_3
XFILLER_95_573 VGND VGND VPWR VPWR sky130_fd_sc_hd__fill_2
XFILLER_95_584 VGND VGND VPWR VPWR sky130_fd_sc_hd__decap_3
XFILLER_35_29 VGND VGND VPWR VPWR sky130_fd_sc_hd__decap_3
XFILLER_70_418 VGND VGND VPWR VPWR sky130_fd_sc_hd__fill_2
XFILLER_82_245 VGND VGND VPWR VPWR sky130_fd_sc_hd__decap_3
XFILLER_82_256 VGND VGND VPWR VPWR sky130_fd_sc_hd__decap_3
XFILLER_35_161 VGND VGND VPWR VPWR sky130_fd_sc_hd__decap_3
XFILLER_35_172 VGND VGND VPWR VPWR sky130_fd_sc_hd__decap_3
XFILLER_51_610 VGND VGND VPWR VPWR sky130_fd_sc_hd__decap_3
XFILLER_51_632 VGND VGND VPWR VPWR sky130_fd_sc_hd__decap_3
XFILLER_63_470 VGND VGND VPWR VPWR sky130_fd_sc_hd__fill_2
XFILLER_23_334 VGND VGND VPWR VPWR sky130_fd_sc_hd__fill_2
XFILLER_51_665 VGND VGND VPWR VPWR sky130_fd_sc_hd__decap_3
X_6815_ _6977_/CLK _6815_/D VGND VGND VPWR VPWR _6815_/Q sky130_fd_sc_hd__dfxtp_2
XFILLER_51_676 VGND VGND VPWR VPWR sky130_fd_sc_hd__decap_3
X_6746_ _6966_/CLK _6746_/D VGND VGND VPWR VPWR _6746_/Q sky130_fd_sc_hd__dfxtp_2
XTAP_TAPCELL_ROW_21_502 VGND VPWR sky130_fd_sc_hd__tapvpwrvgnd_1
XFILLER_50_186 VGND VGND VPWR VPWR sky130_fd_sc_hd__fill_1
XFILLER_50_197 VGND VGND VPWR VPWR sky130_fd_sc_hd__decap_3
XFILLER_51_39 VGND VGND VPWR VPWR sky130_fd_sc_hd__decap_3
X_3958_ _7361_/Q _4501_/A0 _3958_/S VGND VGND VPWR VPWR _7361_/D sky130_fd_sc_hd__mux2_2
X_6677_ _6684_/A VGND VGND VPWR VPWR _6677_/Y sky130_fd_sc_hd__inv_2
X_3889_ _6834_/Q _3889_/A2 _3889_/B1 _6829_/Q _3888_/X VGND VGND VPWR VPWR _3889_/X
+ sky130_fd_sc_hd__a221o_2
XTAP_TAPCELL_ROW_98_1423 VGND VPWR sky130_fd_sc_hd__tapvpwrvgnd_1
X_5628_ _5628_/A _5633_/B VGND VGND VPWR VPWR _7014_/D sky130_fd_sc_hd__or2_2
XFILLER_105_623 VGND VGND VPWR VPWR sky130_fd_sc_hd__decap_3
XFILLER_105_634 VGND VGND VPWR VPWR sky130_fd_sc_hd__decap_3
XFILLER_105_667 VGND VGND VPWR VPWR sky130_fd_sc_hd__decap_3
XFILLER_116_32 VGND VGND VPWR VPWR sky130_fd_sc_hd__decap_3
XFILLER_104_188 VGND VGND VPWR VPWR sky130_fd_sc_hd__fill_1
XFILLER_116_65 VGND VGND VPWR VPWR sky130_fd_sc_hd__decap_3
X_7229_ _7358_/CLK _7229_/D _6509_/Y VGND VGND VPWR VPWR _7229_/Q sky130_fd_sc_hd__dfrtp_2
XFILLER_100_350 VGND VGND VPWR VPWR sky130_fd_sc_hd__decap_3
XFILLER_18_106 VGND VGND VPWR VPWR sky130_fd_sc_hd__decap_3
XFILLER_19_607 VGND VGND VPWR VPWR sky130_fd_sc_hd__decap_3
XFILLER_46_415 VGND VGND VPWR VPWR sky130_fd_sc_hd__decap_3
XFILLER_58_253 VGND VGND VPWR VPWR sky130_fd_sc_hd__decap_3
XFILLER_58_275 VGND VGND VPWR VPWR sky130_fd_sc_hd__decap_3
XFILLER_73_201 VGND VGND VPWR VPWR sky130_fd_sc_hd__decap_3
XFILLER_86_584 VGND VGND VPWR VPWR sky130_fd_sc_hd__decap_3
XTAP_TAPCELL_ROW_29_602 VGND VPWR sky130_fd_sc_hd__tapvpwrvgnd_1
XFILLER_18_139 VGND VGND VPWR VPWR sky130_fd_sc_hd__fill_1
XFILLER_73_234 VGND VGND VPWR VPWR sky130_fd_sc_hd__decap_3
XFILLER_86_595 VGND VGND VPWR VPWR sky130_fd_sc_hd__fill_2
XTAP_TAPCELL_ROW_57_933 VGND VPWR sky130_fd_sc_hd__tapvpwrvgnd_1
XFILLER_27_640 VGND VGND VPWR VPWR sky130_fd_sc_hd__fill_1
XFILLER_27_662 VGND VGND VPWR VPWR sky130_fd_sc_hd__fill_2
XFILLER_73_278 VGND VGND VPWR VPWR sky130_fd_sc_hd__fill_2
XFILLER_92_24 VGND VGND VPWR VPWR sky130_fd_sc_hd__decap_3
XFILLER_92_35 VGND VGND VPWR VPWR sky130_fd_sc_hd__decap_3
XTAP_TAPCELL_ROW_1_260 VGND VPWR sky130_fd_sc_hd__tapvpwrvgnd_1
XTAP_TAPCELL_ROW_107_1541 VGND VPWR sky130_fd_sc_hd__tapvpwrvgnd_1
XTAP_TAPCELL_ROW_107_1530 VGND VPWR sky130_fd_sc_hd__tapvpwrvgnd_1
XFILLER_14_312 VGND VGND VPWR VPWR sky130_fd_sc_hd__decap_3
XFILLER_27_673 VGND VGND VPWR VPWR sky130_fd_sc_hd__fill_2
XFILLER_61_429 VGND VGND VPWR VPWR sky130_fd_sc_hd__decap_3
XFILLER_14_345 VGND VGND VPWR VPWR sky130_fd_sc_hd__decap_3
XFILLER_26_183 VGND VGND VPWR VPWR sky130_fd_sc_hd__decap_3
XFILLER_42_643 VGND VGND VPWR VPWR sky130_fd_sc_hd__fill_1
XFILLER_42_654 VGND VGND VPWR VPWR sky130_fd_sc_hd__decap_3
XTAP_TAPCELL_ROW_37_690 VGND VPWR sky130_fd_sc_hd__tapvpwrvgnd_1
XPHY_EDGE_ROW_1_Left_118 VGND VGND VPWR VPWR sky130_fd_sc_hd__decap_3
XFILLER_41_153 VGND VGND VPWR VPWR sky130_fd_sc_hd__decap_3
XFILLER_42_687 VGND VGND VPWR VPWR sky130_fd_sc_hd__decap_3
XFILLER_41_50 VGND VGND VPWR VPWR sky130_fd_sc_hd__decap_3
XFILLER_6_500 VGND VGND VPWR VPWR sky130_fd_sc_hd__fill_2
XFILLER_6_511 VGND VGND VPWR VPWR sky130_fd_sc_hd__decap_3
XFILLER_10_584 VGND VGND VPWR VPWR sky130_fd_sc_hd__decap_3
XFILLER_6_555 VGND VGND VPWR VPWR sky130_fd_sc_hd__decap_3
XFILLER_108_472 VGND VGND VPWR VPWR sky130_fd_sc_hd__decap_3
XFILLER_108_483 VGND VGND VPWR VPWR sky130_fd_sc_hd__decap_3
XTAP_TAPCELL_ROW_9_360 VGND VPWR sky130_fd_sc_hd__tapvpwrvgnd_1
XTAP_TAPCELL_ROW_71_1106 VGND VPWR sky130_fd_sc_hd__tapvpwrvgnd_1
XFILLER_111_615 VGND VGND VPWR VPWR sky130_fd_sc_hd__fill_1
XFILLER_111_626 VGND VGND VPWR VPWR sky130_fd_sc_hd__decap_3
XFILLER_96_315 VGND VGND VPWR VPWR sky130_fd_sc_hd__decap_3
XFILLER_110_136 VGND VGND VPWR VPWR sky130_fd_sc_hd__decap_3
XFILLER_111_659 VGND VGND VPWR VPWR sky130_fd_sc_hd__decap_3
XFILLER_2_11 VGND VGND VPWR VPWR sky130_fd_sc_hd__decap_3
XFILLER_2_44 VGND VGND VPWR VPWR sky130_fd_sc_hd__decap_3
XFILLER_49_231 VGND VGND VPWR VPWR sky130_fd_sc_hd__decap_3
XFILLER_96_359 VGND VGND VPWR VPWR sky130_fd_sc_hd__decap_3
XFILLER_2_77 VGND VGND VPWR VPWR sky130_fd_sc_hd__decap_3
XFILLER_49_264 VGND VGND VPWR VPWR sky130_fd_sc_hd__decap_3
XFILLER_92_510 VGND VGND VPWR VPWR sky130_fd_sc_hd__fill_1
XFILLER_2_88 VGND VGND VPWR VPWR sky130_fd_sc_hd__decap_3
XFILLER_37_437 VGND VGND VPWR VPWR sky130_fd_sc_hd__decap_3
XFILLER_64_234 VGND VGND VPWR VPWR sky130_fd_sc_hd__decap_3
XTAP_TAPCELL_ROW_69_1079 VGND VPWR sky130_fd_sc_hd__tapvpwrvgnd_1
XFILLER_17_150 VGND VGND VPWR VPWR sky130_fd_sc_hd__decap_3
XFILLER_17_172 VGND VGND VPWR VPWR sky130_fd_sc_hd__decap_3
XFILLER_45_470 VGND VGND VPWR VPWR sky130_fd_sc_hd__fill_1
X_4930_ _6995_/Q _4963_/A _6996_/Q VGND VGND VPWR VPWR _4931_/B sky130_fd_sc_hd__a21oi_2
X_4861_ _6998_/Q _6999_/Q _4912_/A _7000_/Q VGND VGND VPWR VPWR _4862_/B sky130_fd_sc_hd__a31o_2
XTAP_TAPCELL_ROW_82_1235 VGND VPWR sky130_fd_sc_hd__tapvpwrvgnd_1
XFILLER_20_304 VGND VGND VPWR VPWR sky130_fd_sc_hd__decap_3
XFILLER_32_164 VGND VGND VPWR VPWR sky130_fd_sc_hd__decap_3
XFILLER_33_676 VGND VGND VPWR VPWR sky130_fd_sc_hd__decap_3
X_6600_ _6600_/A VGND VGND VPWR VPWR _6600_/Y sky130_fd_sc_hd__inv_2
X_3812_ _3725_/X _3804_/X _3806_/X _3728_/Y _3811_/X VGND VGND VPWR VPWR _3812_/X
+ sky130_fd_sc_hd__a221o_2
XFILLER_32_197 VGND VGND VPWR VPWR sky130_fd_sc_hd__decap_3
X_4792_ _4997_/A1 _7004_/D _4777_/X _4791_/Y VGND VGND VPWR VPWR _4792_/X sky130_fd_sc_hd__a211o_2
XFILLER_20_359 VGND VGND VPWR VPWR sky130_fd_sc_hd__decap_3
X_6531_ _6532_/A VGND VGND VPWR VPWR _6531_/Y sky130_fd_sc_hd__inv_2
X_3743_ _6848_/Q _3892_/A2 _3891_/A2 _6838_/Q _3742_/X VGND VGND VPWR VPWR _3743_/X
+ sky130_fd_sc_hd__a221o_2
X_6462_ _6652_/A VGND VGND VPWR VPWR _6462_/Y sky130_fd_sc_hd__inv_2
X_3674_ _6806_/Q VGND VGND VPWR VPWR _3674_/Y sky130_fd_sc_hd__inv_2
XFILLER_9_393 VGND VGND VPWR VPWR sky130_fd_sc_hd__fill_2
X_6393_ _6553_/A VGND VGND VPWR VPWR _6393_/Y sky130_fd_sc_hd__inv_2
X_5413_ _5413_/A0 _5107_/X _5417_/S VGND VGND VPWR VPWR _7127_/D sky130_fd_sc_hd__mux2_2
X_5344_ _5344_/A0 _5107_/X _5360_/S VGND VGND VPWR VPWR _7159_/D sky130_fd_sc_hd__mux2_2
XFILLER_114_464 VGND VGND VPWR VPWR sky130_fd_sc_hd__decap_3
XTAP_TAPCELL_ROW_93_1364 VGND VPWR sky130_fd_sc_hd__tapvpwrvgnd_1
XFILLER_102_637 VGND VGND VPWR VPWR sky130_fd_sc_hd__decap_3
XFILLER_114_475 VGND VGND VPWR VPWR sky130_fd_sc_hd__fill_1
XFILLER_114_486 VGND VGND VPWR VPWR sky130_fd_sc_hd__decap_3
XFILLER_101_125 VGND VGND VPWR VPWR sky130_fd_sc_hd__decap_3
XFILLER_102_648 VGND VGND VPWR VPWR sky130_fd_sc_hd__decap_3
XFILLER_87_337 VGND VGND VPWR VPWR sky130_fd_sc_hd__fill_2
X_7014_ _7356_/CLK _7014_/D _6294_/Y VGND VGND VPWR VPWR _7014_/Q sky130_fd_sc_hd__dfrtp_2
X_4226_ _4372_/A _4627_/A VGND VGND VPWR VPWR _4620_/A sky130_fd_sc_hd__nor2_2
XFILLER_101_169 VGND VGND VPWR VPWR sky130_fd_sc_hd__decap_3
XFILLER_68_584 VGND VGND VPWR VPWR sky130_fd_sc_hd__decap_3
X_4157_ _4157_/A _4205_/C VGND VGND VPWR VPWR _4158_/B sky130_fd_sc_hd__nand2_2
XFILLER_110_681 VGND VGND VPWR VPWR sky130_fd_sc_hd__decap_3
XFILLER_55_201 VGND VGND VPWR VPWR sky130_fd_sc_hd__decap_3
XFILLER_55_223 VGND VGND VPWR VPWR sky130_fd_sc_hd__fill_1
XFILLER_83_543 VGND VGND VPWR VPWR sky130_fd_sc_hd__fill_2
XFILLER_95_381 VGND VGND VPWR VPWR sky130_fd_sc_hd__fill_2
XFILLER_102_12 VGND VGND VPWR VPWR sky130_fd_sc_hd__decap_3
XFILLER_55_245 VGND VGND VPWR VPWR sky130_fd_sc_hd__decap_3
X_4088_ _7238_/Q _4433_/B _4505_/S _7051_/Q VGND VGND VPWR VPWR _4088_/X sky130_fd_sc_hd__a22o_2
XTAP_TAPCELL_ROW_54_903 VGND VPWR sky130_fd_sc_hd__tapvpwrvgnd_1
XFILLER_102_45 VGND VGND VPWR VPWR sky130_fd_sc_hd__decap_3
XFILLER_15_109 VGND VGND VPWR VPWR sky130_fd_sc_hd__decap_3
XFILLER_102_67 VGND VGND VPWR VPWR sky130_fd_sc_hd__decap_3
XFILLER_24_632 VGND VGND VPWR VPWR sky130_fd_sc_hd__fill_1
XFILLER_70_259 VGND VGND VPWR VPWR sky130_fd_sc_hd__decap_3
XFILLER_62_38 VGND VGND VPWR VPWR sky130_fd_sc_hd__decap_3
XTAP_TAPCELL_ROW_34_660 VGND VPWR sky130_fd_sc_hd__tapvpwrvgnd_1
XFILLER_11_326 VGND VGND VPWR VPWR sky130_fd_sc_hd__decap_3
XFILLER_23_175 VGND VGND VPWR VPWR sky130_fd_sc_hd__decap_3
XFILLER_51_484 VGND VGND VPWR VPWR sky130_fd_sc_hd__decap_3
XTAP_TAPCELL_ROW_62_991 VGND VPWR sky130_fd_sc_hd__tapvpwrvgnd_1
XTAP_TAPCELL_ROW_102_1471 VGND VPWR sky130_fd_sc_hd__tapvpwrvgnd_1
XFILLER_109_214 VGND VGND VPWR VPWR sky130_fd_sc_hd__decap_3
X_6729_ _6911_/CLK _6729_/D VGND VGND VPWR VPWR _6729_/Q sky130_fd_sc_hd__dfxtp_2
XFILLER_109_225 VGND VGND VPWR VPWR sky130_fd_sc_hd__decap_3
XFILLER_109_247 VGND VGND VPWR VPWR sky130_fd_sc_hd__decap_3
XFILLER_11_42 VGND VGND VPWR VPWR sky130_fd_sc_hd__decap_3
XFILLER_105_420 VGND VGND VPWR VPWR sky130_fd_sc_hd__decap_3
XFILLER_87_24 VGND VGND VPWR VPWR sky130_fd_sc_hd__decap_3
XFILLER_105_486 VGND VGND VPWR VPWR sky130_fd_sc_hd__fill_2
XFILLER_105_497 VGND VGND VPWR VPWR sky130_fd_sc_hd__decap_3
XFILLER_78_315 VGND VGND VPWR VPWR sky130_fd_sc_hd__decap_3
XFILLER_87_68 VGND VGND VPWR VPWR sky130_fd_sc_hd__decap_3
XFILLER_78_348 VGND VGND VPWR VPWR sky130_fd_sc_hd__decap_3
XFILLER_59_595 VGND VGND VPWR VPWR sky130_fd_sc_hd__decap_3
XFILLER_74_521 VGND VGND VPWR VPWR sky130_fd_sc_hd__decap_3
XFILLER_100_180 VGND VGND VPWR VPWR sky130_fd_sc_hd__decap_3
XFILLER_46_245 VGND VGND VPWR VPWR sky130_fd_sc_hd__decap_3
XFILLER_34_418 VGND VGND VPWR VPWR sky130_fd_sc_hd__fill_2
XFILLER_36_61 VGND VGND VPWR VPWR sky130_fd_sc_hd__decap_3
XFILLER_74_587 VGND VGND VPWR VPWR sky130_fd_sc_hd__fill_1
XFILLER_74_598 VGND VGND VPWR VPWR sky130_fd_sc_hd__decap_3
XFILLER_15_643 VGND VGND VPWR VPWR sky130_fd_sc_hd__decap_3
XFILLER_42_440 VGND VGND VPWR VPWR sky130_fd_sc_hd__fill_1
XFILLER_61_237 VGND VGND VPWR VPWR sky130_fd_sc_hd__decap_3
XFILLER_99_9 VGND VGND VPWR VPWR sky130_fd_sc_hd__decap_3
XFILLER_14_197 VGND VGND VPWR VPWR sky130_fd_sc_hd__decap_3
XFILLER_52_82 VGND VGND VPWR VPWR sky130_fd_sc_hd__fill_2
Xhold809 _6974_/Q VGND VGND VPWR VPWR _6974_/D sky130_fd_sc_hd__dlygate4sd3_1
XTAP_TAPCELL_ROW_12_398 VGND VPWR sky130_fd_sc_hd__tapvpwrvgnd_1
XFILLER_115_217 VGND VGND VPWR VPWR sky130_fd_sc_hd__decap_3
XFILLER_115_228 VGND VGND VPWR VPWR sky130_fd_sc_hd__decap_3
X_3390_ _7155_/Q _4339_/B1 _3379_/X _3389_/X VGND VGND VPWR VPWR _3390_/X sky130_fd_sc_hd__a211o_2
XFILLER_69_337 VGND VGND VPWR VPWR sky130_fd_sc_hd__decap_3
XFILLER_97_657 VGND VGND VPWR VPWR sky130_fd_sc_hd__decap_3
X_5060_ _5581_/S _5045_/X _5059_/X _4467_/B VGND VGND VPWR VPWR _5060_/X sky130_fd_sc_hd__a22o_2
XFILLER_111_489 VGND VGND VPWR VPWR sky130_fd_sc_hd__decap_3
XFILLER_28_3 VGND VGND VPWR VPWR sky130_fd_sc_hd__fill_1
XFILLER_84_307 VGND VGND VPWR VPWR sky130_fd_sc_hd__fill_1
X_4011_ _7342_/Q _3947_/S _4437_/B1 _7374_/Q _4429_/C1 VGND VGND VPWR VPWR _4011_/X
+ sky130_fd_sc_hd__a221o_2
XFILLER_97_679 VGND VGND VPWR VPWR sky130_fd_sc_hd__decap_3
XFILLER_77_370 VGND VGND VPWR VPWR sky130_fd_sc_hd__decap_3
XFILLER_37_245 VGND VGND VPWR VPWR sky130_fd_sc_hd__decap_3
XFILLER_37_278 VGND VGND VPWR VPWR sky130_fd_sc_hd__fill_2
XFILLER_52_215 VGND VGND VPWR VPWR sky130_fd_sc_hd__decap_3
XFILLER_65_587 VGND VGND VPWR VPWR sky130_fd_sc_hd__fill_1
XFILLER_80_524 VGND VGND VPWR VPWR sky130_fd_sc_hd__decap_3
XFILLER_52_259 VGND VGND VPWR VPWR sky130_fd_sc_hd__decap_3
XFILLER_80_557 VGND VGND VPWR VPWR sky130_fd_sc_hd__decap_3
X_4913_ _4913_/A1 _3762_/X _4910_/Y _6997_/D _4836_/S VGND VGND VPWR VPWR _4913_/X
+ sky130_fd_sc_hd__o32a_2
XFILLER_20_112 VGND VGND VPWR VPWR sky130_fd_sc_hd__decap_3
XFILLER_21_646 VGND VGND VPWR VPWR sky130_fd_sc_hd__fill_2
XFILLER_60_270 VGND VGND VPWR VPWR sky130_fd_sc_hd__decap_3
X_4844_ _4633_/A _4111_/B _4842_/X _4843_/Y _4948_/A VGND VGND VPWR VPWR _4855_/A
+ sky130_fd_sc_hd__a311oi_2
XFILLER_20_134 VGND VGND VPWR VPWR sky130_fd_sc_hd__decap_3
XFILLER_20_156 VGND VGND VPWR VPWR sky130_fd_sc_hd__decap_3
X_4775_ _4775_/A _4775_/B VGND VGND VPWR VPWR _7004_/D sky130_fd_sc_hd__nor2_2
X_6514_ _6578_/A VGND VGND VPWR VPWR _6514_/Y sky130_fd_sc_hd__inv_2
X_3726_ _3714_/X _3721_/X _3724_/X _3725_/X VGND VGND VPWR VPWR _3726_/X sky130_fd_sc_hd__a22o_2
XFILLER_106_217 VGND VGND VPWR VPWR sky130_fd_sc_hd__decap_3
X_6445_ _6604_/A VGND VGND VPWR VPWR _6445_/Y sky130_fd_sc_hd__inv_2
X_6376_ _6568_/A VGND VGND VPWR VPWR _6376_/Y sky130_fd_sc_hd__inv_2
XFILLER_102_412 VGND VGND VPWR VPWR sky130_fd_sc_hd__decap_3
X_5327_ _5327_/A0 _4978_/X _5327_/S VGND VGND VPWR VPWR _7167_/D sky130_fd_sc_hd__mux2_2
XFILLER_114_283 VGND VGND VPWR VPWR sky130_fd_sc_hd__decap_3
XFILLER_87_134 VGND VGND VPWR VPWR sky130_fd_sc_hd__decap_3
XFILLER_88_657 VGND VGND VPWR VPWR sky130_fd_sc_hd__decap_3
XFILLER_57_27 VGND VGND VPWR VPWR sky130_fd_sc_hd__decap_3
XFILLER_75_307 VGND VGND VPWR VPWR sky130_fd_sc_hd__decap_3
XFILLER_87_167 VGND VGND VPWR VPWR sky130_fd_sc_hd__fill_1
X_5258_ _5258_/A0 _4945_/X _5262_/S VGND VGND VPWR VPWR _7201_/D sky130_fd_sc_hd__mux2_2
XFILLER_102_489 VGND VGND VPWR VPWR sky130_fd_sc_hd__decap_3
XFILLER_68_392 VGND VGND VPWR VPWR sky130_fd_sc_hd__decap_3
X_4209_ _4633_/A _4903_/A _4845_/A _4890_/B VGND VGND VPWR VPWR _4384_/A sky130_fd_sc_hd__and4_2
XFILLER_113_33 VGND VGND VPWR VPWR sky130_fd_sc_hd__decap_3
XFILLER_28_256 VGND VGND VPWR VPWR sky130_fd_sc_hd__decap_3
XFILLER_113_66 VGND VGND VPWR VPWR sky130_fd_sc_hd__decap_3
XFILLER_43_204 VGND VGND VPWR VPWR sky130_fd_sc_hd__decap_3
XFILLER_56_587 VGND VGND VPWR VPWR sky130_fd_sc_hd__fill_1
XFILLER_73_15 VGND VGND VPWR VPWR sky130_fd_sc_hd__fill_1
XTAP_TAPCELL_ROW_104_1500 VGND VPWR sky130_fd_sc_hd__tapvpwrvgnd_1
XFILLER_113_99 VGND VGND VPWR VPWR sky130_fd_sc_hd__decap_3
XFILLER_71_546 VGND VGND VPWR VPWR sky130_fd_sc_hd__fill_1
XFILLER_71_579 VGND VGND VPWR VPWR sky130_fd_sc_hd__decap_3
XFILLER_11_156 VGND VGND VPWR VPWR sky130_fd_sc_hd__decap_3
XFILLER_7_105 VGND VGND VPWR VPWR sky130_fd_sc_hd__decap_3
XPHY_EDGE_ROW_91_Left_208 VGND VGND VPWR VPWR sky130_fd_sc_hd__decap_3
XFILLER_11_178 VGND VGND VPWR VPWR sky130_fd_sc_hd__fill_2
XFILLER_7_116 VGND VGND VPWR VPWR sky130_fd_sc_hd__decap_3
XFILLER_8_639 VGND VGND VPWR VPWR sky130_fd_sc_hd__decap_3
XFILLER_22_74 VGND VGND VPWR VPWR sky130_fd_sc_hd__decap_3
XFILLER_22_85 VGND VGND VPWR VPWR sky130_fd_sc_hd__decap_3
XFILLER_7_149 VGND VGND VPWR VPWR sky130_fd_sc_hd__decap_3
XFILLER_98_12 VGND VGND VPWR VPWR sky130_fd_sc_hd__decap_3
XFILLER_112_209 VGND VGND VPWR VPWR sky130_fd_sc_hd__decap_3
XFILLER_3_366 VGND VGND VPWR VPWR sky130_fd_sc_hd__decap_3
XFILLER_79_602 VGND VGND VPWR VPWR sky130_fd_sc_hd__decap_3
XFILLER_3_399 VGND VGND VPWR VPWR sky130_fd_sc_hd__decap_3
XFILLER_78_156 VGND VGND VPWR VPWR sky130_fd_sc_hd__decap_3
XFILLER_79_679 VGND VGND VPWR VPWR sky130_fd_sc_hd__decap_3
XFILLER_14_9 VGND VGND VPWR VPWR sky130_fd_sc_hd__decap_3
XFILLER_59_381 VGND VGND VPWR VPWR sky130_fd_sc_hd__decap_3
XFILLER_94_638 VGND VGND VPWR VPWR sky130_fd_sc_hd__decap_3
XFILLER_19_234 VGND VGND VPWR VPWR sky130_fd_sc_hd__fill_1
XFILLER_19_256 VGND VGND VPWR VPWR sky130_fd_sc_hd__decap_3
XFILLER_47_60 VGND VGND VPWR VPWR sky130_fd_sc_hd__decap_3
XFILLER_74_351 VGND VGND VPWR VPWR sky130_fd_sc_hd__fill_1
XFILLER_34_215 VGND VGND VPWR VPWR sky130_fd_sc_hd__decap_3
XFILLER_47_93 VGND VGND VPWR VPWR sky130_fd_sc_hd__decap_3
XFILLER_34_248 VGND VGND VPWR VPWR sky130_fd_sc_hd__decap_3
XTAP_TAPCELL_ROW_66_1049 VGND VPWR sky130_fd_sc_hd__tapvpwrvgnd_1
XTAP_TAPCELL_ROW_66_1038 VGND VPWR sky130_fd_sc_hd__tapvpwrvgnd_1
XFILLER_15_462 VGND VGND VPWR VPWR sky130_fd_sc_hd__fill_2
XFILLER_34_259 VGND VGND VPWR VPWR sky130_fd_sc_hd__decap_3
XTAP_TAPCELL_ROW_45_788 VGND VPWR sky130_fd_sc_hd__tapvpwrvgnd_1
XTAP_TAPCELL_ROW_17_457 VGND VPWR sky130_fd_sc_hd__tapvpwrvgnd_1
XFILLER_30_421 VGND VGND VPWR VPWR sky130_fd_sc_hd__fill_2
XFILLER_97_6 VGND VGND VPWR VPWR sky130_fd_sc_hd__decap_3
XFILLER_30_465 VGND VGND VPWR VPWR sky130_fd_sc_hd__decap_3
XFILLER_8_32 VGND VGND VPWR VPWR sky130_fd_sc_hd__decap_3
XFILLER_8_65 VGND VGND VPWR VPWR sky130_fd_sc_hd__decap_3
Xhold606 _6900_/Q VGND VGND VPWR VPWR _6900_/D sky130_fd_sc_hd__dlygate4sd3_1
Xhold617 _6914_/Q VGND VGND VPWR VPWR _6914_/D sky130_fd_sc_hd__dlygate4sd3_1
X_4491_ _4491_/A0 _7302_/Q _4499_/S VGND VGND VPWR VPWR _7334_/D sky130_fd_sc_hd__mux2_2
XFILLER_116_548 VGND VGND VPWR VPWR sky130_fd_sc_hd__decap_3
Xhold628 _6872_/Q VGND VGND VPWR VPWR _6872_/D sky130_fd_sc_hd__dlygate4sd3_1
Xhold639 _6725_/Q VGND VGND VPWR VPWR _6725_/D sky130_fd_sc_hd__dlygate4sd3_1
X_3442_ _3442_/A _3442_/B VGND VGND VPWR VPWR _4394_/A sky130_fd_sc_hd__nand2_2
XTAP_TAPCELL_ROW_77_1178 VGND VPWR sky130_fd_sc_hd__tapvpwrvgnd_1
XFILLER_69_101 VGND VGND VPWR VPWR sky130_fd_sc_hd__decap_3
X_3373_ _3560_/B _3370_/Y _4159_/A2 VGND VGND VPWR VPWR _3373_/X sky130_fd_sc_hd__a21o_2
X_5112_ _4292_/A _3594_/B _4295_/X VGND VGND VPWR VPWR _5113_/B sky130_fd_sc_hd__a21oi_2
XTAP_TAPCELL_ROW_90_1334 VGND VPWR sky130_fd_sc_hd__tapvpwrvgnd_1
XFILLER_57_318 VGND VGND VPWR VPWR sky130_fd_sc_hd__decap_3
XFILLER_69_167 VGND VGND VPWR VPWR sky130_fd_sc_hd__fill_1
XFILLER_97_476 VGND VGND VPWR VPWR sky130_fd_sc_hd__decap_3
XFILLER_69_178 VGND VGND VPWR VPWR sky130_fd_sc_hd__fill_2
XFILLER_84_104 VGND VGND VPWR VPWR sky130_fd_sc_hd__decap_3
XFILLER_85_649 VGND VGND VPWR VPWR sky130_fd_sc_hd__decap_3
X_5043_ _6988_/Q _5066_/A VGND VGND VPWR VPWR _5044_/B sky130_fd_sc_hd__nor2_2
XFILLER_27_19 VGND VGND VPWR VPWR sky130_fd_sc_hd__decap_3
XFILLER_65_340 VGND VGND VPWR VPWR sky130_fd_sc_hd__decap_3
XFILLER_53_502 VGND VGND VPWR VPWR sky130_fd_sc_hd__fill_2
XFILLER_93_671 VGND VGND VPWR VPWR sky130_fd_sc_hd__fill_1
XFILLER_93_682 VGND VGND VPWR VPWR sky130_fd_sc_hd__fill_2
XFILLER_80_332 VGND VGND VPWR VPWR sky130_fd_sc_hd__decap_3
XFILLER_92_192 VGND VGND VPWR VPWR sky130_fd_sc_hd__decap_3
X_6994_ _7369_/CLK _6994_/D _6274_/Y VGND VGND VPWR VPWR _6994_/Q sky130_fd_sc_hd__dfrtp_2
XFILLER_25_259 VGND VGND VPWR VPWR sky130_fd_sc_hd__decap_3
XFILLER_40_207 VGND VGND VPWR VPWR sky130_fd_sc_hd__decap_3
XFILLER_53_579 VGND VGND VPWR VPWR sky130_fd_sc_hd__fill_2
XFILLER_80_365 VGND VGND VPWR VPWR sky130_fd_sc_hd__decap_3
XFILLER_80_376 VGND VGND VPWR VPWR sky130_fd_sc_hd__decap_3
X_4827_ _4827_/A _4827_/B VGND VGND VPWR VPWR _4827_/X sky130_fd_sc_hd__xor2_2
XFILLER_21_498 VGND VGND VPWR VPWR sky130_fd_sc_hd__decap_3
X_4758_ _7004_/Q _4804_/A VGND VGND VPWR VPWR _4777_/B sky130_fd_sc_hd__nand2_2
XFILLER_107_526 VGND VGND VPWR VPWR sky130_fd_sc_hd__decap_3
X_4689_ _7002_/Q _4834_/A _4688_/X _7003_/Q VGND VGND VPWR VPWR _4804_/A sky130_fd_sc_hd__o211a_2
X_3709_ _3682_/A _3708_/X _3709_/B1 VGND VGND VPWR VPWR _3709_/X sky130_fd_sc_hd__a21o_2
XFILLER_107_559 VGND VGND VPWR VPWR sky130_fd_sc_hd__fill_1
XFILLER_108_44 VGND VGND VPWR VPWR sky130_fd_sc_hd__decap_3
X_6428_ _6558_/A VGND VGND VPWR VPWR _6428_/Y sky130_fd_sc_hd__inv_2
XFILLER_108_77 VGND VGND VPWR VPWR sky130_fd_sc_hd__decap_3
XFILLER_115_570 VGND VGND VPWR VPWR sky130_fd_sc_hd__decap_3
XFILLER_68_26 VGND VGND VPWR VPWR sky130_fd_sc_hd__fill_2
XFILLER_108_88 VGND VGND VPWR VPWR sky130_fd_sc_hd__decap_3
XFILLER_88_421 VGND VGND VPWR VPWR sky130_fd_sc_hd__decap_3
X_6359_ _6385_/A VGND VGND VPWR VPWR _6359_/Y sky130_fd_sc_hd__inv_2
XFILLER_102_253 VGND VGND VPWR VPWR sky130_fd_sc_hd__fill_1
XFILLER_76_616 VGND VGND VPWR VPWR sky130_fd_sc_hd__decap_3
XFILLER_102_297 VGND VGND VPWR VPWR sky130_fd_sc_hd__decap_3
XTAP_TAPCELL_ROW_110_1570 VGND VPWR sky130_fd_sc_hd__tapvpwrvgnd_1
XFILLER_56_340 VGND VGND VPWR VPWR sky130_fd_sc_hd__decap_3
XFILLER_84_47 VGND VGND VPWR VPWR sky130_fd_sc_hd__decap_3
XFILLER_91_608 VGND VGND VPWR VPWR sky130_fd_sc_hd__fill_2
XFILLER_17_30 VGND VGND VPWR VPWR sky130_fd_sc_hd__decap_3
XFILLER_29_598 VGND VGND VPWR VPWR sky130_fd_sc_hd__decap_3
XFILLER_84_682 VGND VGND VPWR VPWR sky130_fd_sc_hd__decap_3
XFILLER_90_118 VGND VGND VPWR VPWR sky130_fd_sc_hd__decap_3
XFILLER_71_376 VGND VGND VPWR VPWR sky130_fd_sc_hd__decap_3
XFILLER_12_421 VGND VGND VPWR VPWR sky130_fd_sc_hd__fill_2
XTAP_TAPCELL_ROW_14_416 VGND VPWR sky130_fd_sc_hd__tapvpwrvgnd_1
XFILLER_33_51 VGND VGND VPWR VPWR sky130_fd_sc_hd__decap_3
XTAP_TAPCELL_ROW_42_758 VGND VPWR sky130_fd_sc_hd__tapvpwrvgnd_1
XFILLER_33_73 VGND VGND VPWR VPWR sky130_fd_sc_hd__fill_2
XFILLER_33_84 VGND VGND VPWR VPWR sky130_fd_sc_hd__decap_3
XFILLER_8_414 VGND VGND VPWR VPWR sky130_fd_sc_hd__decap_3
XFILLER_8_469 VGND VGND VPWR VPWR sky130_fd_sc_hd__decap_3
XFILLER_113_529 VGND VGND VPWR VPWR sky130_fd_sc_hd__fill_2
XFILLER_3_152 VGND VGND VPWR VPWR sky130_fd_sc_hd__decap_3
XFILLER_4_675 VGND VGND VPWR VPWR sky130_fd_sc_hd__decap_3
XFILLER_106_592 VGND VGND VPWR VPWR sky130_fd_sc_hd__decap_3
XFILLER_3_174 VGND VGND VPWR VPWR sky130_fd_sc_hd__decap_3
XFILLER_39_307 VGND VGND VPWR VPWR sky130_fd_sc_hd__decap_3
XFILLER_58_81 VGND VGND VPWR VPWR sky130_fd_sc_hd__decap_3
XFILLER_66_126 VGND VGND VPWR VPWR sky130_fd_sc_hd__decap_3
XFILLER_79_487 VGND VGND VPWR VPWR sky130_fd_sc_hd__decap_3
XFILLER_94_424 VGND VGND VPWR VPWR sky130_fd_sc_hd__fill_1
XFILLER_12_6 VGND VGND VPWR VPWR sky130_fd_sc_hd__decap_3
XFILLER_66_159 VGND VGND VPWR VPWR sky130_fd_sc_hd__fill_2
XFILLER_82_619 VGND VGND VPWR VPWR sky130_fd_sc_hd__decap_3
XFILLER_35_502 VGND VGND VPWR VPWR sky130_fd_sc_hd__fill_2
XFILLER_75_671 VGND VGND VPWR VPWR sky130_fd_sc_hd__fill_1
XFILLER_75_682 VGND VGND VPWR VPWR sky130_fd_sc_hd__decap_3
XFILLER_81_107 VGND VGND VPWR VPWR sky130_fd_sc_hd__decap_3
XFILLER_74_170 VGND VGND VPWR VPWR sky130_fd_sc_hd__decap_3
XFILLER_62_365 VGND VGND VPWR VPWR sky130_fd_sc_hd__decap_3
XFILLER_90_685 VGND VGND VPWR VPWR sky130_fd_sc_hd__decap_3
X_3991_ _5151_/A _3991_/B VGND VGND VPWR VPWR _3991_/X sky130_fd_sc_hd__or2_2
XFILLER_15_270 VGND VGND VPWR VPWR sky130_fd_sc_hd__decap_3
XFILLER_22_218 VGND VGND VPWR VPWR sky130_fd_sc_hd__decap_3
XFILLER_50_527 VGND VGND VPWR VPWR sky130_fd_sc_hd__decap_3
XFILLER_95_3 VGND VGND VPWR VPWR sky130_fd_sc_hd__decap_3
XFILLER_15_281 VGND VGND VPWR VPWR sky130_fd_sc_hd__decap_3
X_7400_ _7406_/CLK _7400_/D _6680_/Y VGND VGND VPWR VPWR _7400_/Q sky130_fd_sc_hd__dfrtp_2
X_5661_ _5661_/A _5661_/B _5661_/C _5661_/D VGND VGND VPWR VPWR _5661_/X sky130_fd_sc_hd__and4_2
XFILLER_30_284 VGND VGND VPWR VPWR sky130_fd_sc_hd__decap_3
X_4612_ _4612_/A _4612_/B VGND VGND VPWR VPWR _5114_/B sky130_fd_sc_hd__nor2_2
XFILLER_116_301 VGND VGND VPWR VPWR sky130_fd_sc_hd__decap_3
X_7331_ _7363_/CLK _7331_/D _6611_/Y VGND VGND VPWR VPWR _7331_/Q sky130_fd_sc_hd__dfrtp_2
XFILLER_116_334 VGND VGND VPWR VPWR sky130_fd_sc_hd__fill_2
XFILLER_116_356 VGND VGND VPWR VPWR sky130_fd_sc_hd__decap_3
X_7262_ _7264_/CLK _7262_/D _6542_/Y VGND VGND VPWR VPWR _7262_/Q sky130_fd_sc_hd__dfrtp_2
X_4474_ _4474_/A0 _4540_/A _4478_/S VGND VGND VPWR VPWR _7342_/D sky130_fd_sc_hd__mux2_2
X_7193_ _7358_/CLK _7193_/D _6473_/Y VGND VGND VPWR VPWR _7193_/Q sky130_fd_sc_hd__dfrtp_2
X_3425_ _3589_/A _3591_/A _3589_/B _3590_/C VGND VGND VPWR VPWR _3527_/A sky130_fd_sc_hd__o31a_2
XFILLER_112_551 VGND VGND VPWR VPWR sky130_fd_sc_hd__decap_3
XFILLER_38_18 VGND VGND VPWR VPWR sky130_fd_sc_hd__decap_3
XFILLER_85_402 VGND VGND VPWR VPWR sky130_fd_sc_hd__decap_3
XFILLER_97_240 VGND VGND VPWR VPWR sky130_fd_sc_hd__decap_3
X_3356_ _5118_/D _3354_/X _3355_/Y _3330_/A VGND VGND VPWR VPWR _4537_/B sky130_fd_sc_hd__a22o_2
XFILLER_112_595 VGND VGND VPWR VPWR sky130_fd_sc_hd__decap_3
XFILLER_38_29 VGND VGND VPWR VPWR sky130_fd_sc_hd__fill_1
XFILLER_58_627 VGND VGND VPWR VPWR sky130_fd_sc_hd__decap_3
XFILLER_85_435 VGND VGND VPWR VPWR sky130_fd_sc_hd__fill_2
XFILLER_97_273 VGND VGND VPWR VPWR sky130_fd_sc_hd__decap_3
XFILLER_97_284 VGND VGND VPWR VPWR sky130_fd_sc_hd__decap_3
Xhold1103 _7378_/Q VGND VGND VPWR VPWR _3915_/A0 sky130_fd_sc_hd__dlygate4sd3_1
Xhold1114 _7303_/Q VGND VGND VPWR VPWR _4554_/A sky130_fd_sc_hd__dlygate4sd3_1
Xhold1125 _7144_/Q VGND VGND VPWR VPWR _5377_/A0 sky130_fd_sc_hd__dlygate4sd3_1
Xhold1136 _7297_/Q VGND VGND VPWR VPWR _4567_/A sky130_fd_sc_hd__dlygate4sd3_1
Xhold1147 _7180_/Q VGND VGND VPWR VPWR _5300_/A0 sky130_fd_sc_hd__dlygate4sd3_1
Xhold1158 _7170_/Q VGND VGND VPWR VPWR _5321_/A0 sky130_fd_sc_hd__dlygate4sd3_1
X_5026_ _5026_/A _5026_/B VGND VGND VPWR VPWR _6990_/D sky130_fd_sc_hd__nor2_2
XFILLER_26_502 VGND VGND VPWR VPWR sky130_fd_sc_hd__fill_2
XFILLER_66_660 VGND VGND VPWR VPWR sky130_fd_sc_hd__decap_3
Xhold1169 _7302_/Q VGND VGND VPWR VPWR _4556_/A sky130_fd_sc_hd__dlygate4sd3_1
XFILLER_38_395 VGND VGND VPWR VPWR sky130_fd_sc_hd__decap_3
XFILLER_65_181 VGND VGND VPWR VPWR sky130_fd_sc_hd__decap_3
XFILLER_41_505 VGND VGND VPWR VPWR sky130_fd_sc_hd__decap_3
XFILLER_53_343 VGND VGND VPWR VPWR sky130_fd_sc_hd__decap_3
XFILLER_53_365 VGND VGND VPWR VPWR sky130_fd_sc_hd__decap_3
X_6977_ _6977_/CLK _6977_/D VGND VGND VPWR VPWR _6977_/Q sky130_fd_sc_hd__dfxtp_2
XFILLER_110_12 VGND VGND VPWR VPWR sky130_fd_sc_hd__decap_3
XFILLER_80_162 VGND VGND VPWR VPWR sky130_fd_sc_hd__decap_3
XFILLER_81_685 VGND VGND VPWR VPWR sky130_fd_sc_hd__decap_3
XFILLER_110_56 VGND VGND VPWR VPWR sky130_fd_sc_hd__decap_3
XFILLER_80_195 VGND VGND VPWR VPWR sky130_fd_sc_hd__fill_1
XFILLER_21_240 VGND VGND VPWR VPWR sky130_fd_sc_hd__decap_3
XFILLER_70_27 VGND VGND VPWR VPWR sky130_fd_sc_hd__fill_1
XFILLER_70_38 VGND VGND VPWR VPWR sky130_fd_sc_hd__decap_3
XFILLER_21_284 VGND VGND VPWR VPWR sky130_fd_sc_hd__decap_3
XFILLER_107_301 VGND VGND VPWR VPWR sky130_fd_sc_hd__decap_3
XFILLER_107_334 VGND VGND VPWR VPWR sky130_fd_sc_hd__fill_2
XFILLER_107_345 VGND VGND VPWR VPWR sky130_fd_sc_hd__decap_3
XFILLER_79_47 VGND VGND VPWR VPWR sky130_fd_sc_hd__fill_1
XFILLER_79_69 VGND VGND VPWR VPWR sky130_fd_sc_hd__decap_3
XFILLER_1_612 VGND VGND VPWR VPWR sky130_fd_sc_hd__decap_3
XFILLER_1_623 VGND VGND VPWR VPWR sky130_fd_sc_hd__decap_3
Xhold981 _7401_/Q VGND VGND VPWR VPWR hold981/X sky130_fd_sc_hd__dlygate4sd3_1
Xhold970 _7026_/Q VGND VGND VPWR VPWR _5602_/A sky130_fd_sc_hd__dlygate4sd3_1
XFILLER_0_144 VGND VGND VPWR VPWR sky130_fd_sc_hd__decap_3
XFILLER_103_540 VGND VGND VPWR VPWR sky130_fd_sc_hd__fill_2
XFILLER_1_656 VGND VGND VPWR VPWR sky130_fd_sc_hd__decap_3
XFILLER_49_605 VGND VGND VPWR VPWR sky130_fd_sc_hd__decap_3
Xhold992 _7376_/Q VGND VGND VPWR VPWR hold992/X sky130_fd_sc_hd__dlygate4sd3_1
XFILLER_49_638 VGND VGND VPWR VPWR sky130_fd_sc_hd__decap_3
XFILLER_76_435 VGND VGND VPWR VPWR sky130_fd_sc_hd__decap_3
XFILLER_88_262 VGND VGND VPWR VPWR sky130_fd_sc_hd__decap_3
XFILLER_95_24 VGND VGND VPWR VPWR sky130_fd_sc_hd__fill_1
XFILLER_28_40 VGND VGND VPWR VPWR sky130_fd_sc_hd__decap_3
XFILLER_48_159 VGND VGND VPWR VPWR sky130_fd_sc_hd__decap_3
XFILLER_57_671 VGND VGND VPWR VPWR sky130_fd_sc_hd__fill_1
XFILLER_57_682 VGND VGND VPWR VPWR sky130_fd_sc_hd__decap_3
XFILLER_64_619 VGND VGND VPWR VPWR sky130_fd_sc_hd__decap_3
XTAP_TAPCELL_ROW_47_817 VGND VPWR sky130_fd_sc_hd__tapvpwrvgnd_1
XFILLER_44_321 VGND VGND VPWR VPWR sky130_fd_sc_hd__decap_3
XFILLER_56_181 VGND VGND VPWR VPWR sky130_fd_sc_hd__fill_1
XFILLER_56_192 VGND VGND VPWR VPWR sky130_fd_sc_hd__decap_3
XFILLER_72_641 VGND VGND VPWR VPWR sky130_fd_sc_hd__decap_3
XFILLER_91_438 VGND VGND VPWR VPWR sky130_fd_sc_hd__decap_3
XFILLER_44_354 VGND VGND VPWR VPWR sky130_fd_sc_hd__decap_3
XFILLER_44_365 VGND VGND VPWR VPWR sky130_fd_sc_hd__fill_1
XTAP_TAPCELL_ROW_63_1008 VGND VPWR sky130_fd_sc_hd__tapvpwrvgnd_1
XFILLER_44_61 VGND VGND VPWR VPWR sky130_fd_sc_hd__decap_3
XTAP_TAPCELL_ROW_27_574 VGND VPWR sky130_fd_sc_hd__tapvpwrvgnd_1
XFILLER_44_83 VGND VGND VPWR VPWR sky130_fd_sc_hd__fill_1
XFILLER_81_9 VGND VGND VPWR VPWR sky130_fd_sc_hd__decap_3
XFILLER_8_211 VGND VGND VPWR VPWR sky130_fd_sc_hd__decap_3
XFILLER_12_295 VGND VGND VPWR VPWR sky130_fd_sc_hd__fill_2
XFILLER_8_244 VGND VGND VPWR VPWR sky130_fd_sc_hd__decap_3
XFILLER_60_60 VGND VGND VPWR VPWR sky130_fd_sc_hd__decap_3
XFILLER_8_266 VGND VGND VPWR VPWR sky130_fd_sc_hd__decap_3
Xoutput508 _5649_/X VGND VGND VPWR VPWR instruction_out[26] sky130_fd_sc_hd__clkdlybuf4s25_1
XFILLER_5_33 VGND VGND VPWR VPWR sky130_fd_sc_hd__decap_3
Xoutput519 _5646_/Y VGND VGND VPWR VPWR instruction_out[9] sky130_fd_sc_hd__clkdlybuf4s25_1
XTAP_TAPCELL_ROW_74_1137 VGND VPWR sky130_fd_sc_hd__tapvpwrvgnd_1
XFILLER_99_505 VGND VGND VPWR VPWR sky130_fd_sc_hd__decap_3
XFILLER_113_337 VGND VGND VPWR VPWR sky130_fd_sc_hd__decap_3
XFILLER_4_483 VGND VGND VPWR VPWR sky130_fd_sc_hd__fill_1
XFILLER_5_66 VGND VGND VPWR VPWR sky130_fd_sc_hd__decap_3
XFILLER_5_99 VGND VGND VPWR VPWR sky130_fd_sc_hd__decap_3
X_4190_ _7263_/Q _4356_/A2 _4348_/B1 _7135_/Q _4189_/X VGND VGND VPWR VPWR _4637_/B
+ sky130_fd_sc_hd__a221o_2
XFILLER_79_262 VGND VGND VPWR VPWR sky130_fd_sc_hd__decap_3
XFILLER_79_284 VGND VGND VPWR VPWR sky130_fd_sc_hd__decap_3
XFILLER_10_3 VGND VGND VPWR VPWR sky130_fd_sc_hd__decap_3
XFILLER_39_137 VGND VGND VPWR VPWR sky130_fd_sc_hd__decap_3
XFILLER_39_159 VGND VGND VPWR VPWR sky130_fd_sc_hd__decap_3
XFILLER_94_221 VGND VGND VPWR VPWR sky130_fd_sc_hd__decap_3
XFILLER_48_660 VGND VGND VPWR VPWR sky130_fd_sc_hd__decap_3
XFILLER_82_416 VGND VGND VPWR VPWR sky130_fd_sc_hd__decap_3
XFILLER_94_265 VGND VGND VPWR VPWR sky130_fd_sc_hd__decap_3
XFILLER_35_310 VGND VGND VPWR VPWR sky130_fd_sc_hd__decap_3
XFILLER_63_641 VGND VGND VPWR VPWR sky130_fd_sc_hd__decap_3
XFILLER_85_90 VGND VGND VPWR VPWR sky130_fd_sc_hd__decap_3
X_6900_ _6966_/CLK _6900_/D VGND VGND VPWR VPWR _6900_/Q sky130_fd_sc_hd__dfxtp_2
XFILLER_23_505 VGND VGND VPWR VPWR sky130_fd_sc_hd__fill_1
XFILLER_35_343 VGND VGND VPWR VPWR sky130_fd_sc_hd__decap_3
XFILLER_35_365 VGND VGND VPWR VPWR sky130_fd_sc_hd__decap_3
X_6831_ _6929_/CLK _6831_/D VGND VGND VPWR VPWR _6831_/Q sky130_fd_sc_hd__dfxtp_2
XTAP_TAPCELL_ROW_85_1266 VGND VPWR sky130_fd_sc_hd__tapvpwrvgnd_1
XFILLER_62_184 VGND VGND VPWR VPWR sky130_fd_sc_hd__decap_3
XTAP_TAPCELL_ROW_85_1277 VGND VPWR sky130_fd_sc_hd__tapvpwrvgnd_1
X_6762_ _6911_/CLK _6762_/D VGND VGND VPWR VPWR _6762_/Q sky130_fd_sc_hd__dfxtp_2
X_6693_ _7384_/CLK _6693_/D VGND VGND VPWR VPWR _6693_/Q sky130_fd_sc_hd__dfxtp_2
X_5644_ _6981_/Q _5130_/C _3340_/B _6980_/Q VGND VGND VPWR VPWR _5644_/X sky130_fd_sc_hd__o211a_2
X_7314_ _7322_/CLK _7314_/D _6594_/Y VGND VGND VPWR VPWR _7314_/Q sky130_fd_sc_hd__dfrtp_2
X_5575_ hold963/X _4960_/A _5010_/D VGND VGND VPWR VPWR _7042_/D sky130_fd_sc_hd__a21o_2
XFILLER_116_164 VGND VGND VPWR VPWR sky130_fd_sc_hd__decap_3
X_4526_ _4526_/A0 _7284_/Q _4528_/B VGND VGND VPWR VPWR _7316_/D sky130_fd_sc_hd__mux2_2
XFILLER_116_175 VGND VGND VPWR VPWR sky130_fd_sc_hd__decap_3
XFILLER_116_197 VGND VGND VPWR VPWR sky130_fd_sc_hd__decap_3
X_7245_ _7374_/CLK _7245_/D _6525_/Y VGND VGND VPWR VPWR _7245_/Q sky130_fd_sc_hd__dfrtp_2
X_4457_ _4720_/A _4720_/B _4456_/X VGND VGND VPWR VPWR _4457_/X sky130_fd_sc_hd__o21a_2
X_7176_ _7368_/CLK _7176_/D _6456_/Y VGND VGND VPWR VPWR _7176_/Q sky130_fd_sc_hd__dfrtp_2
XFILLER_100_510 VGND VGND VPWR VPWR sky130_fd_sc_hd__decap_3
XFILLER_105_12 VGND VGND VPWR VPWR sky130_fd_sc_hd__decap_3
X_4388_ _7273_/Q _4437_/A2 _4385_/X _4387_/X VGND VGND VPWR VPWR _4388_/X sky130_fd_sc_hd__a211o_2
XFILLER_105_45 VGND VGND VPWR VPWR sky130_fd_sc_hd__decap_3
XFILLER_85_221 VGND VGND VPWR VPWR sky130_fd_sc_hd__decap_3
XFILLER_85_243 VGND VGND VPWR VPWR sky130_fd_sc_hd__decap_3
X_3339_ _3319_/X _5238_/B _3329_/Y _3339_/C1 VGND VGND VPWR VPWR _3339_/Y sky130_fd_sc_hd__a211oi_4
XFILLER_105_67 VGND VGND VPWR VPWR sky130_fd_sc_hd__decap_3
XFILLER_39_671 VGND VGND VPWR VPWR sky130_fd_sc_hd__fill_1
XFILLER_65_38 VGND VGND VPWR VPWR sky130_fd_sc_hd__decap_3
XFILLER_73_427 VGND VGND VPWR VPWR sky130_fd_sc_hd__decap_3
XFILLER_100_598 VGND VGND VPWR VPWR sky130_fd_sc_hd__decap_3
XFILLER_39_682 VGND VGND VPWR VPWR sky130_fd_sc_hd__decap_3
XFILLER_45_129 VGND VGND VPWR VPWR sky130_fd_sc_hd__fill_1
XFILLER_73_449 VGND VGND VPWR VPWR sky130_fd_sc_hd__decap_3
X_5009_ _5009_/A _5009_/B VGND VGND VPWR VPWR _5010_/D sky130_fd_sc_hd__nor2_2
XFILLER_14_505 VGND VGND VPWR VPWR sky130_fd_sc_hd__decap_3
XFILLER_26_365 VGND VGND VPWR VPWR sky130_fd_sc_hd__decap_3
XFILLER_38_192 VGND VGND VPWR VPWR sky130_fd_sc_hd__decap_3
XFILLER_53_140 VGND VGND VPWR VPWR sky130_fd_sc_hd__decap_3
XFILLER_54_663 VGND VGND VPWR VPWR sky130_fd_sc_hd__decap_3
XFILLER_41_302 VGND VGND VPWR VPWR sky130_fd_sc_hd__decap_3
XFILLER_53_151 VGND VGND VPWR VPWR sky130_fd_sc_hd__decap_3
XFILLER_81_15 VGND VGND VPWR VPWR sky130_fd_sc_hd__decap_3
XFILLER_81_493 VGND VGND VPWR VPWR sky130_fd_sc_hd__decap_3
XFILLER_41_335 VGND VGND VPWR VPWR sky130_fd_sc_hd__fill_1
XFILLER_41_346 VGND VGND VPWR VPWR sky130_fd_sc_hd__decap_3
XTAP_TAPCELL_ROW_24_544 VGND VPWR sky130_fd_sc_hd__tapvpwrvgnd_1
XFILLER_14_53 VGND VGND VPWR VPWR sky130_fd_sc_hd__decap_3
XFILLER_41_379 VGND VGND VPWR VPWR sky130_fd_sc_hd__fill_1
XTAP_TAPCELL_ROW_52_875 VGND VPWR sky130_fd_sc_hd__tapvpwrvgnd_1
XFILLER_5_203 VGND VGND VPWR VPWR sky130_fd_sc_hd__fill_1
XFILLER_108_643 VGND VGND VPWR VPWR sky130_fd_sc_hd__fill_1
XFILLER_108_654 VGND VGND VPWR VPWR sky130_fd_sc_hd__decap_3
XFILLER_30_41 VGND VGND VPWR VPWR sky130_fd_sc_hd__decap_3
XFILLER_5_225 VGND VGND VPWR VPWR sky130_fd_sc_hd__decap_3
XFILLER_30_63 VGND VGND VPWR VPWR sky130_fd_sc_hd__decap_3
XFILLER_5_269 VGND VGND VPWR VPWR sky130_fd_sc_hd__decap_3
XFILLER_107_175 VGND VGND VPWR VPWR sky130_fd_sc_hd__decap_3
XFILLER_30_85 VGND VGND VPWR VPWR sky130_fd_sc_hd__decap_3
XFILLER_1_420 VGND VGND VPWR VPWR sky130_fd_sc_hd__decap_3
XFILLER_96_519 VGND VGND VPWR VPWR sky130_fd_sc_hd__decap_3
XFILLER_1_464 VGND VGND VPWR VPWR sky130_fd_sc_hd__decap_3
XFILLER_76_221 VGND VGND VPWR VPWR sky130_fd_sc_hd__fill_2
XFILLER_64_416 VGND VGND VPWR VPWR sky130_fd_sc_hd__decap_3
XFILLER_76_265 VGND VGND VPWR VPWR sky130_fd_sc_hd__decap_3
XFILLER_29_181 VGND VGND VPWR VPWR sky130_fd_sc_hd__fill_1
XFILLER_36_129 VGND VGND VPWR VPWR sky130_fd_sc_hd__decap_3
XFILLER_76_298 VGND VGND VPWR VPWR sky130_fd_sc_hd__decap_3
XPHY_EDGE_ROW_101_Right_101 VGND VGND VPWR VPWR sky130_fd_sc_hd__decap_3
XFILLER_17_332 VGND VGND VPWR VPWR sky130_fd_sc_hd__decap_3
XFILLER_45_641 VGND VGND VPWR VPWR sky130_fd_sc_hd__decap_3
XFILLER_55_60 VGND VGND VPWR VPWR sky130_fd_sc_hd__fill_2
XFILLER_91_279 VGND VGND VPWR VPWR sky130_fd_sc_hd__fill_1
XFILLER_45_685 VGND VGND VPWR VPWR sky130_fd_sc_hd__decap_3
XFILLER_55_93 VGND VGND VPWR VPWR sky130_fd_sc_hd__decap_3
XFILLER_60_622 VGND VGND VPWR VPWR sky130_fd_sc_hd__decap_3
XFILLER_72_471 VGND VGND VPWR VPWR sky130_fd_sc_hd__decap_3
XFILLER_60_666 VGND VGND VPWR VPWR sky130_fd_sc_hd__decap_3
XFILLER_58_3 VGND VGND VPWR VPWR sky130_fd_sc_hd__fill_1
X_5360_ _5360_/A0 _4470_/X _5360_/S VGND VGND VPWR VPWR _7151_/D sky130_fd_sc_hd__mux2_2
XFILLER_99_302 VGND VGND VPWR VPWR sky130_fd_sc_hd__decap_3
XFILLER_114_613 VGND VGND VPWR VPWR sky130_fd_sc_hd__decap_3
X_4311_ _4311_/A _4311_/B _4311_/C VGND VGND VPWR VPWR _4311_/X sky130_fd_sc_hd__or3_2
XFILLER_99_335 VGND VGND VPWR VPWR sky130_fd_sc_hd__fill_1
XFILLER_113_134 VGND VGND VPWR VPWR sky130_fd_sc_hd__decap_3
XFILLER_114_657 VGND VGND VPWR VPWR sky130_fd_sc_hd__decap_3
XFILLER_87_508 VGND VGND VPWR VPWR sky130_fd_sc_hd__decap_3
X_7030_ _7384_/CLK _7030_/D _6310_/Y VGND VGND VPWR VPWR _7030_/Q sky130_fd_sc_hd__dfrtp_2
XFILLER_99_357 VGND VGND VPWR VPWR sky130_fd_sc_hd__decap_3
XFILLER_101_329 VGND VGND VPWR VPWR sky130_fd_sc_hd__decap_3
XFILLER_113_167 VGND VGND VPWR VPWR sky130_fd_sc_hd__fill_1
XFILLER_113_178 VGND VGND VPWR VPWR sky130_fd_sc_hd__decap_3
XFILLER_95_541 VGND VGND VPWR VPWR sky130_fd_sc_hd__decap_3
X_4173_ _7072_/Q VGND VGND VPWR VPWR _4173_/Y sky130_fd_sc_hd__inv_2
XFILLER_27_107 VGND VGND VPWR VPWR sky130_fd_sc_hd__decap_3
XFILLER_28_619 VGND VGND VPWR VPWR sky130_fd_sc_hd__decap_3
XFILLER_67_287 VGND VGND VPWR VPWR sky130_fd_sc_hd__decap_3
XFILLER_95_596 VGND VGND VPWR VPWR sky130_fd_sc_hd__decap_3
XFILLER_35_140 VGND VGND VPWR VPWR sky130_fd_sc_hd__decap_3
XFILLER_82_268 VGND VGND VPWR VPWR sky130_fd_sc_hd__fill_1
XFILLER_23_302 VGND VGND VPWR VPWR sky130_fd_sc_hd__fill_2
XFILLER_35_184 VGND VGND VPWR VPWR sky130_fd_sc_hd__decap_3
XFILLER_50_132 VGND VGND VPWR VPWR sky130_fd_sc_hd__decap_3
XFILLER_51_644 VGND VGND VPWR VPWR sky130_fd_sc_hd__decap_3
Xplace460 _6979_/Q VGND VGND VPWR VPWR _3362_/A sky130_fd_sc_hd__buf_2
X_6814_ _6965_/CLK _6814_/D VGND VGND VPWR VPWR _6814_/Q sky130_fd_sc_hd__dfxtp_2
XFILLER_50_165 VGND VGND VPWR VPWR sky130_fd_sc_hd__decap_3
XFILLER_51_688 VGND VGND VPWR VPWR sky130_fd_sc_hd__decap_3
X_6745_ _6978_/CLK _6745_/D VGND VGND VPWR VPWR _6745_/Q sky130_fd_sc_hd__dfxtp_2
XTAP_TAPCELL_ROW_21_503 VGND VPWR sky130_fd_sc_hd__tapvpwrvgnd_1
X_6676_ _6684_/A VGND VGND VPWR VPWR _6676_/Y sky130_fd_sc_hd__inv_2
X_3888_ _6844_/Q _3892_/A2 _3891_/B1 _6839_/Q VGND VGND VPWR VPWR _3888_/X sky130_fd_sc_hd__a22o_2
XTAP_TAPCELL_ROW_98_1424 VGND VPWR sky130_fd_sc_hd__tapvpwrvgnd_1
XFILLER_105_613 VGND VGND VPWR VPWR sky130_fd_sc_hd__decap_3
XFILLER_105_646 VGND VGND VPWR VPWR sky130_fd_sc_hd__decap_3
XFILLER_2_206 VGND VGND VPWR VPWR sky130_fd_sc_hd__decap_3
XFILLER_2_228 VGND VGND VPWR VPWR sky130_fd_sc_hd__fill_2
X_4509_ _4509_/A1 _3398_/Y _4244_/X VGND VGND VPWR VPWR _7325_/D sky130_fd_sc_hd__a21o_2
XFILLER_104_134 VGND VGND VPWR VPWR sky130_fd_sc_hd__decap_3
XFILLER_105_679 VGND VGND VPWR VPWR sky130_fd_sc_hd__decap_3
XFILLER_78_519 VGND VGND VPWR VPWR sky130_fd_sc_hd__decap_3
X_7228_ _7230_/CLK _7228_/D _6508_/Y VGND VGND VPWR VPWR _7228_/Q sky130_fd_sc_hd__dfrtp_2
XFILLER_116_44 VGND VGND VPWR VPWR sky130_fd_sc_hd__decap_3
XFILLER_116_77 VGND VGND VPWR VPWR sky130_fd_sc_hd__decap_3
XFILLER_58_221 VGND VGND VPWR VPWR sky130_fd_sc_hd__decap_3
X_7159_ clkload6/A _7159_/D _6439_/Y VGND VGND VPWR VPWR _7159_/Q sky130_fd_sc_hd__dfrtp_2
XFILLER_100_340 VGND VGND VPWR VPWR sky130_fd_sc_hd__fill_2
XFILLER_100_362 VGND VGND VPWR VPWR sky130_fd_sc_hd__fill_2
XFILLER_58_265 VGND VGND VPWR VPWR sky130_fd_sc_hd__fill_2
XTAP_TAPCELL_ROW_29_603 VGND VPWR sky130_fd_sc_hd__tapvpwrvgnd_1
XFILLER_100_384 VGND VGND VPWR VPWR sky130_fd_sc_hd__decap_3
XFILLER_18_118 VGND VGND VPWR VPWR sky130_fd_sc_hd__decap_3
XFILLER_58_287 VGND VGND VPWR VPWR sky130_fd_sc_hd__fill_1
XFILLER_73_213 VGND VGND VPWR VPWR sky130_fd_sc_hd__fill_2
XTAP_TAPCELL_ROW_57_934 VGND VPWR sky130_fd_sc_hd__tapvpwrvgnd_1
XFILLER_61_408 VGND VGND VPWR VPWR sky130_fd_sc_hd__decap_3
XFILLER_73_246 VGND VGND VPWR VPWR sky130_fd_sc_hd__decap_3
Xclkbuf_leaf_38_clk clkbuf_leaf_4_clk/A VGND VGND VPWR VPWR _7356_/CLK sky130_fd_sc_hd__clkbuf_16
XTAP_TAPCELL_ROW_1_261 VGND VPWR sky130_fd_sc_hd__tapvpwrvgnd_1
XTAP_TAPCELL_ROW_107_1531 VGND VPWR sky130_fd_sc_hd__tapvpwrvgnd_1
XFILLER_26_162 VGND VGND VPWR VPWR sky130_fd_sc_hd__decap_3
XFILLER_42_622 VGND VGND VPWR VPWR sky130_fd_sc_hd__decap_3
XFILLER_54_471 VGND VGND VPWR VPWR sky130_fd_sc_hd__decap_3
XFILLER_92_47 VGND VGND VPWR VPWR sky130_fd_sc_hd__decap_3
XFILLER_92_69 VGND VGND VPWR VPWR sky130_fd_sc_hd__fill_2
XFILLER_25_41 VGND VGND VPWR VPWR sky130_fd_sc_hd__decap_3
XFILLER_26_195 VGND VGND VPWR VPWR sky130_fd_sc_hd__fill_1
XTAP_TAPCELL_ROW_37_691 VGND VPWR sky130_fd_sc_hd__tapvpwrvgnd_1
XFILLER_14_357 VGND VGND VPWR VPWR sky130_fd_sc_hd__decap_3
XFILLER_25_74 VGND VGND VPWR VPWR sky130_fd_sc_hd__decap_3
XFILLER_25_96 VGND VGND VPWR VPWR sky130_fd_sc_hd__decap_3
XFILLER_42_666 VGND VGND VPWR VPWR sky130_fd_sc_hd__decap_3
XFILLER_41_198 VGND VGND VPWR VPWR sky130_fd_sc_hd__decap_3
XFILLER_10_530 VGND VGND VPWR VPWR sky130_fd_sc_hd__fill_2
XFILLER_10_541 VGND VGND VPWR VPWR sky130_fd_sc_hd__decap_3
XFILLER_108_440 VGND VGND VPWR VPWR sky130_fd_sc_hd__decap_3
XFILLER_44_9 VGND VGND VPWR VPWR sky130_fd_sc_hd__decap_3
XFILLER_69_508 VGND VGND VPWR VPWR sky130_fd_sc_hd__fill_1
XTAP_TAPCELL_ROW_9_361 VGND VPWR sky130_fd_sc_hd__tapvpwrvgnd_1
XTAP_TAPCELL_ROW_71_1107 VGND VPWR sky130_fd_sc_hd__tapvpwrvgnd_1
XPHY_EDGE_ROW_102_Left_219 VGND VGND VPWR VPWR sky130_fd_sc_hd__decap_3
XFILLER_111_638 VGND VGND VPWR VPWR sky130_fd_sc_hd__decap_3
XFILLER_104_690 VGND VGND VPWR VPWR sky130_fd_sc_hd__fill_2
XFILLER_2_23 VGND VGND VPWR VPWR sky130_fd_sc_hd__fill_2
XFILLER_77_541 VGND VGND VPWR VPWR sky130_fd_sc_hd__decap_3
XFILLER_96_338 VGND VGND VPWR VPWR sky130_fd_sc_hd__decap_3
XFILLER_2_56 VGND VGND VPWR VPWR sky130_fd_sc_hd__decap_3
XFILLER_49_243 VGND VGND VPWR VPWR sky130_fd_sc_hd__decap_3
XFILLER_37_427 VGND VGND VPWR VPWR sky130_fd_sc_hd__decap_3
XFILLER_37_449 VGND VGND VPWR VPWR sky130_fd_sc_hd__decap_3
XFILLER_49_276 VGND VGND VPWR VPWR sky130_fd_sc_hd__decap_3
XFILLER_64_213 VGND VGND VPWR VPWR sky130_fd_sc_hd__decap_3
XFILLER_18_641 VGND VGND VPWR VPWR sky130_fd_sc_hd__decap_3
XFILLER_52_408 VGND VGND VPWR VPWR sky130_fd_sc_hd__decap_3
XFILLER_66_92 VGND VGND VPWR VPWR sky130_fd_sc_hd__fill_2
XFILLER_92_555 VGND VGND VPWR VPWR sky130_fd_sc_hd__decap_3
Xclkbuf_leaf_29_clk clkbuf_3_2__f_clk/X VGND VGND VPWR VPWR _6978_/CLK sky130_fd_sc_hd__clkbuf_16
XFILLER_17_162 VGND VGND VPWR VPWR sky130_fd_sc_hd__decap_3
XFILLER_18_685 VGND VGND VPWR VPWR sky130_fd_sc_hd__decap_3
XFILLER_17_184 VGND VGND VPWR VPWR sky130_fd_sc_hd__decap_3
X_4860_ _4687_/B _4859_/Y _4777_/A VGND VGND VPWR VPWR _4860_/Y sky130_fd_sc_hd__o21ai_2
XTAP_TAPCELL_ROW_82_1236 VGND VPWR sky130_fd_sc_hd__tapvpwrvgnd_1
XPHY_EDGE_ROW_111_Left_228 VGND VGND VPWR VPWR sky130_fd_sc_hd__decap_3
XFILLER_60_474 VGND VGND VPWR VPWR sky130_fd_sc_hd__fill_2
XFILLER_82_80 VGND VGND VPWR VPWR sky130_fd_sc_hd__decap_3
XFILLER_82_91 VGND VGND VPWR VPWR sky130_fd_sc_hd__decap_3
X_3811_ _3923_/A1 _3808_/X _3810_/X _3741_/X VGND VGND VPWR VPWR _3811_/X sky130_fd_sc_hd__a22o_2
XFILLER_32_176 VGND VGND VPWR VPWR sky130_fd_sc_hd__decap_3
X_6530_ _6600_/A VGND VGND VPWR VPWR _6530_/Y sky130_fd_sc_hd__inv_2
X_4791_ _4466_/A _5664_/A _3697_/Y _3509_/B VGND VGND VPWR VPWR _4791_/Y sky130_fd_sc_hd__a211oi_2
X_3742_ _6833_/Q _3656_/Y _3891_/B1 _6843_/Q VGND VGND VPWR VPWR _3742_/X sky130_fd_sc_hd__a22o_2
X_6461_ _6651_/A VGND VGND VPWR VPWR _6461_/Y sky130_fd_sc_hd__inv_2
X_3673_ _6856_/Q _6864_/Q _6904_/Q _6912_/Q _3991_/B _3665_/B VGND VGND VPWR VPWR
+ _3673_/X sky130_fd_sc_hd__mux4_2
X_6392_ _6522_/A VGND VGND VPWR VPWR _6392_/Y sky130_fd_sc_hd__inv_2
XFILLER_114_421 VGND VGND VPWR VPWR sky130_fd_sc_hd__decap_3
XFILLER_114_443 VGND VGND VPWR VPWR sky130_fd_sc_hd__fill_2
XTAP_TAPCELL_ROW_93_1365 VGND VPWR sky130_fd_sc_hd__tapvpwrvgnd_1
XFILLER_99_143 VGND VGND VPWR VPWR sky130_fd_sc_hd__fill_2
XFILLER_101_104 VGND VGND VPWR VPWR sky130_fd_sc_hd__decap_3
XFILLER_102_616 VGND VGND VPWR VPWR sky130_fd_sc_hd__decap_3
X_5274_ _5274_/A0 _5079_/X _5274_/S VGND VGND VPWR VPWR _7193_/D sky130_fd_sc_hd__mux2_2
XFILLER_114_498 VGND VGND VPWR VPWR sky130_fd_sc_hd__decap_3
XFILLER_68_530 VGND VGND VPWR VPWR sky130_fd_sc_hd__fill_2
X_7013_ clkload9/A _7013_/D _6293_/Y VGND VGND VPWR VPWR _7013_/Q sky130_fd_sc_hd__dfrtp_2
X_4225_ _4371_/A _4371_/B _4224_/C VGND VGND VPWR VPWR _4627_/A sky130_fd_sc_hd__a21oi_2
XFILLER_110_660 VGND VGND VPWR VPWR sky130_fd_sc_hd__decap_3
XFILLER_95_360 VGND VGND VPWR VPWR sky130_fd_sc_hd__decap_3
X_4156_ _4157_/A _4205_/C VGND VGND VPWR VPWR _4158_/A sky130_fd_sc_hd__or2_2
XFILLER_28_416 VGND VGND VPWR VPWR sky130_fd_sc_hd__decap_3
XFILLER_46_18 VGND VGND VPWR VPWR sky130_fd_sc_hd__decap_3
XFILLER_55_213 VGND VGND VPWR VPWR sky130_fd_sc_hd__decap_3
XFILLER_55_257 VGND VGND VPWR VPWR sky130_fd_sc_hd__decap_3
X_4087_ _7078_/Q _4432_/A2 _4205_/A _4086_/X VGND VGND VPWR VPWR _4095_/A sky130_fd_sc_hd__o211ai_2
XTAP_TAPCELL_ROW_54_904 VGND VPWR sky130_fd_sc_hd__tapvpwrvgnd_1
XFILLER_24_600 VGND VGND VPWR VPWR sky130_fd_sc_hd__fill_2
XFILLER_55_279 VGND VGND VPWR VPWR sky130_fd_sc_hd__fill_1
XFILLER_102_79 VGND VGND VPWR VPWR sky130_fd_sc_hd__decap_3
XFILLER_23_110 VGND VGND VPWR VPWR sky130_fd_sc_hd__fill_2
XFILLER_63_290 VGND VGND VPWR VPWR sky130_fd_sc_hd__decap_3
XFILLER_70_249 VGND VGND VPWR VPWR sky130_fd_sc_hd__decap_3
XFILLER_11_305 VGND VGND VPWR VPWR sky130_fd_sc_hd__decap_3
XFILLER_23_132 VGND VGND VPWR VPWR sky130_fd_sc_hd__decap_3
XFILLER_23_154 VGND VGND VPWR VPWR sky130_fd_sc_hd__decap_3
Xplace290 _3656_/Y VGND VGND VPWR VPWR _3853_/B1 sky130_fd_sc_hd__buf_2
XTAP_TAPCELL_ROW_34_661 VGND VPWR sky130_fd_sc_hd__tapvpwrvgnd_1
XFILLER_23_187 VGND VGND VPWR VPWR sky130_fd_sc_hd__decap_3
X_4989_ _5032_/A _5032_/B VGND VGND VPWR VPWR _4989_/X sky130_fd_sc_hd__or2b_2
XTAP_TAPCELL_ROW_62_992 VGND VPWR sky130_fd_sc_hd__tapvpwrvgnd_1
XTAP_TAPCELL_ROW_102_1472 VGND VPWR sky130_fd_sc_hd__tapvpwrvgnd_1
X_6728_ _6978_/CLK _6728_/D VGND VGND VPWR VPWR _6728_/Q sky130_fd_sc_hd__dfxtp_2
X_6659_ _6660_/A VGND VGND VPWR VPWR _6659_/Y sky130_fd_sc_hd__inv_2
XFILLER_11_21 VGND VGND VPWR VPWR sky130_fd_sc_hd__decap_3
XFILLER_11_54 VGND VGND VPWR VPWR sky130_fd_sc_hd__fill_2
XFILLER_11_76 VGND VGND VPWR VPWR sky130_fd_sc_hd__decap_3
XFILLER_105_432 VGND VGND VPWR VPWR sky130_fd_sc_hd__decap_3
XFILLER_78_327 VGND VGND VPWR VPWR sky130_fd_sc_hd__decap_3
XFILLER_87_36 VGND VGND VPWR VPWR sky130_fd_sc_hd__decap_3
XTAP_TAPCELL_ROW_6_320 VGND VPWR sky130_fd_sc_hd__tapvpwrvgnd_1
XFILLER_101_660 VGND VGND VPWR VPWR sky130_fd_sc_hd__decap_3
XFILLER_19_405 VGND VGND VPWR VPWR sky130_fd_sc_hd__decap_3
XFILLER_101_682 VGND VGND VPWR VPWR sky130_fd_sc_hd__decap_3
XFILLER_74_533 VGND VGND VPWR VPWR sky130_fd_sc_hd__decap_3
XFILLER_86_371 VGND VGND VPWR VPWR sky130_fd_sc_hd__decap_3
XFILLER_74_555 VGND VGND VPWR VPWR sky130_fd_sc_hd__fill_2
XFILLER_36_40 VGND VGND VPWR VPWR sky130_fd_sc_hd__decap_3
XFILLER_36_73 VGND VGND VPWR VPWR sky130_fd_sc_hd__decap_3
XFILLER_46_279 VGND VGND VPWR VPWR sky130_fd_sc_hd__fill_2
XFILLER_61_205 VGND VGND VPWR VPWR sky130_fd_sc_hd__decap_3
XFILLER_61_249 VGND VGND VPWR VPWR sky130_fd_sc_hd__decap_3
XFILLER_14_132 VGND VGND VPWR VPWR sky130_fd_sc_hd__decap_3
XFILLER_30_614 VGND VGND VPWR VPWR sky130_fd_sc_hd__decap_3
XFILLER_14_176 VGND VGND VPWR VPWR sky130_fd_sc_hd__decap_3
XFILLER_52_94 VGND VGND VPWR VPWR sky130_fd_sc_hd__fill_1
XTAP_TAPCELL_ROW_12_399 VGND VPWR sky130_fd_sc_hd__tapvpwrvgnd_1
XFILLER_108_292 VGND VGND VPWR VPWR sky130_fd_sc_hd__decap_3
XFILLER_42_6 VGND VGND VPWR VPWR sky130_fd_sc_hd__decap_3
XFILLER_97_603 VGND VGND VPWR VPWR sky130_fd_sc_hd__fill_1
XFILLER_2_570 VGND VGND VPWR VPWR sky130_fd_sc_hd__fill_1
XFILLER_69_327 VGND VGND VPWR VPWR sky130_fd_sc_hd__decap_3
XFILLER_69_349 VGND VGND VPWR VPWR sky130_fd_sc_hd__decap_3
XFILLER_96_113 VGND VGND VPWR VPWR sky130_fd_sc_hd__decap_3
XFILLER_96_124 VGND VGND VPWR VPWR sky130_fd_sc_hd__decap_3
XFILLER_97_669 VGND VGND VPWR VPWR sky130_fd_sc_hd__decap_3
XFILLER_84_319 VGND VGND VPWR VPWR sky130_fd_sc_hd__decap_3
XFILLER_37_202 VGND VGND VPWR VPWR sky130_fd_sc_hd__decap_3
XFILLER_65_522 VGND VGND VPWR VPWR sky130_fd_sc_hd__fill_2
XFILLER_77_393 VGND VGND VPWR VPWR sky130_fd_sc_hd__decap_3
XFILLER_92_330 VGND VGND VPWR VPWR sky130_fd_sc_hd__decap_3
XFILLER_80_503 VGND VGND VPWR VPWR sky130_fd_sc_hd__decap_3
XFILLER_92_363 VGND VGND VPWR VPWR sky130_fd_sc_hd__fill_1
XFILLER_45_290 VGND VGND VPWR VPWR sky130_fd_sc_hd__fill_1
XFILLER_52_227 VGND VGND VPWR VPWR sky130_fd_sc_hd__decap_3
XFILLER_80_536 VGND VGND VPWR VPWR sky130_fd_sc_hd__decap_3
XFILLER_92_396 VGND VGND VPWR VPWR sky130_fd_sc_hd__decap_3
X_4912_ _4912_/A _4912_/B VGND VGND VPWR VPWR _6997_/D sky130_fd_sc_hd__nor2_2
XFILLER_33_441 VGND VGND VPWR VPWR sky130_fd_sc_hd__decap_3
XFILLER_33_452 VGND VGND VPWR VPWR sky130_fd_sc_hd__fill_1
XFILLER_80_569 VGND VGND VPWR VPWR sky130_fd_sc_hd__decap_3
XFILLER_21_614 VGND VGND VPWR VPWR sky130_fd_sc_hd__fill_2
X_4843_ _4111_/B _4842_/X _4633_/A VGND VGND VPWR VPWR _4843_/Y sky130_fd_sc_hd__a21oi_2
XTAP_TAPCELL_ROW_31_620 VGND VPWR sky130_fd_sc_hd__tapvpwrvgnd_1
XFILLER_21_669 VGND VGND VPWR VPWR sky130_fd_sc_hd__decap_3
XFILLER_60_293 VGND VGND VPWR VPWR sky130_fd_sc_hd__decap_3
X_4774_ _7004_/Q _4801_/A VGND VGND VPWR VPWR _4775_/B sky130_fd_sc_hd__nor2_2
XFILLER_20_168 VGND VGND VPWR VPWR sky130_fd_sc_hd__decap_3
X_6513_ _6578_/A VGND VGND VPWR VPWR _6513_/Y sky130_fd_sc_hd__inv_2
X_3725_ _3735_/A _3741_/B _3733_/C VGND VGND VPWR VPWR _3725_/X sky130_fd_sc_hd__and3_2
Xclkbuf_leaf_9_clk clkload2/A VGND VGND VPWR VPWR _7365_/CLK sky130_fd_sc_hd__clkbuf_16
X_6444_ _6604_/A VGND VGND VPWR VPWR _6444_/Y sky130_fd_sc_hd__inv_2
XFILLER_106_229 VGND VGND VPWR VPWR sky130_fd_sc_hd__decap_3
X_3656_ _3991_/B _3665_/B VGND VGND VPWR VPWR _3656_/Y sky130_fd_sc_hd__nor2_2
X_6375_ _6568_/A VGND VGND VPWR VPWR _6375_/Y sky130_fd_sc_hd__inv_2
X_3587_ _3599_/A _3600_/A VGND VGND VPWR VPWR _4292_/B sky130_fd_sc_hd__or2_4
XFILLER_114_251 VGND VGND VPWR VPWR sky130_fd_sc_hd__fill_1
XFILLER_87_102 VGND VGND VPWR VPWR sky130_fd_sc_hd__fill_2
XFILLER_102_424 VGND VGND VPWR VPWR sky130_fd_sc_hd__decap_3
XFILLER_102_468 VGND VGND VPWR VPWR sky130_fd_sc_hd__decap_3
XFILLER_57_39 VGND VGND VPWR VPWR sky130_fd_sc_hd__decap_3
XFILLER_87_146 VGND VGND VPWR VPWR sky130_fd_sc_hd__decap_3
XFILLER_88_669 VGND VGND VPWR VPWR sky130_fd_sc_hd__decap_3
X_4208_ _4886_/A _4208_/B VGND VGND VPWR VPWR _4903_/A sky130_fd_sc_hd__nor2_2
XFILLER_113_12 VGND VGND VPWR VPWR sky130_fd_sc_hd__decap_3
XFILLER_68_371 VGND VGND VPWR VPWR sky130_fd_sc_hd__decap_3
XFILLER_96_680 VGND VGND VPWR VPWR sky130_fd_sc_hd__decap_3
X_5188_ _5188_/A _5194_/B VGND VGND VPWR VPWR _7234_/D sky130_fd_sc_hd__and2_2
XTAP_TAPCELL_ROW_39_720 VGND VPWR sky130_fd_sc_hd__tapvpwrvgnd_1
XFILLER_113_45 VGND VGND VPWR VPWR sky130_fd_sc_hd__decap_3
XFILLER_28_246 VGND VGND VPWR VPWR sky130_fd_sc_hd__decap_3
XFILLER_56_544 VGND VGND VPWR VPWR sky130_fd_sc_hd__decap_3
XFILLER_83_330 VGND VGND VPWR VPWR sky130_fd_sc_hd__decap_3
XFILLER_95_190 VGND VGND VPWR VPWR sky130_fd_sc_hd__decap_3
X_4139_ _4207_/A _4642_/B VGND VGND VPWR VPWR _4886_/A sky130_fd_sc_hd__nor2_2
XFILLER_113_78 VGND VGND VPWR VPWR sky130_fd_sc_hd__decap_3
XFILLER_28_268 VGND VGND VPWR VPWR sky130_fd_sc_hd__decap_3
XFILLER_73_27 VGND VGND VPWR VPWR sky130_fd_sc_hd__decap_3
XFILLER_83_374 VGND VGND VPWR VPWR sky130_fd_sc_hd__fill_2
XFILLER_43_238 VGND VGND VPWR VPWR sky130_fd_sc_hd__decap_3
XFILLER_83_396 VGND VGND VPWR VPWR sky130_fd_sc_hd__decap_3
XTAP_TAPCELL_ROW_104_1501 VGND VPWR sky130_fd_sc_hd__tapvpwrvgnd_1
XFILLER_36_290 VGND VGND VPWR VPWR sky130_fd_sc_hd__fill_1
XFILLER_11_113 VGND VGND VPWR VPWR sky130_fd_sc_hd__decap_3
XFILLER_24_485 VGND VGND VPWR VPWR sky130_fd_sc_hd__fill_2
XFILLER_24_496 VGND VGND VPWR VPWR sky130_fd_sc_hd__decap_3
XFILLER_11_146 VGND VGND VPWR VPWR sky130_fd_sc_hd__decap_3
XFILLER_51_293 VGND VGND VPWR VPWR sky130_fd_sc_hd__decap_3
XFILLER_22_42 VGND VGND VPWR VPWR sky130_fd_sc_hd__decap_3
XFILLER_7_128 VGND VGND VPWR VPWR sky130_fd_sc_hd__decap_3
XFILLER_20_691 VGND VGND VPWR VPWR sky130_fd_sc_hd__fill_1
XFILLER_22_53 VGND VGND VPWR VPWR sky130_fd_sc_hd__decap_3
XFILLER_22_97 VGND VGND VPWR VPWR sky130_fd_sc_hd__decap_3
XTAP_TAPCELL_ROW_115_1630 VGND VPWR sky130_fd_sc_hd__tapvpwrvgnd_1
XFILLER_98_57 VGND VGND VPWR VPWR sky130_fd_sc_hd__decap_3
XFILLER_105_240 VGND VGND VPWR VPWR sky130_fd_sc_hd__decap_3
XFILLER_105_262 VGND VGND VPWR VPWR sky130_fd_sc_hd__decap_3
XFILLER_3_378 VGND VGND VPWR VPWR sky130_fd_sc_hd__decap_3
XFILLER_79_614 VGND VGND VPWR VPWR sky130_fd_sc_hd__fill_2
XFILLER_105_295 VGND VGND VPWR VPWR sky130_fd_sc_hd__decap_3
XFILLER_78_135 VGND VGND VPWR VPWR sky130_fd_sc_hd__decap_3
XFILLER_79_647 VGND VGND VPWR VPWR sky130_fd_sc_hd__decap_3
XFILLER_79_658 VGND VGND VPWR VPWR sky130_fd_sc_hd__decap_3
XFILLER_19_202 VGND VGND VPWR VPWR sky130_fd_sc_hd__decap_3
XFILLER_87_691 VGND VGND VPWR VPWR sky130_fd_sc_hd__fill_1
XFILLER_93_116 VGND VGND VPWR VPWR sky130_fd_sc_hd__decap_3
XFILLER_47_72 VGND VGND VPWR VPWR sky130_fd_sc_hd__decap_3
XFILLER_59_393 VGND VGND VPWR VPWR sky130_fd_sc_hd__decap_3
XFILLER_19_268 VGND VGND VPWR VPWR sky130_fd_sc_hd__decap_3
XFILLER_74_374 VGND VGND VPWR VPWR sky130_fd_sc_hd__decap_3
XFILLER_34_227 VGND VGND VPWR VPWR sky130_fd_sc_hd__decap_3
XFILLER_62_547 VGND VGND VPWR VPWR sky130_fd_sc_hd__decap_3
XTAP_TAPCELL_ROW_66_1039 VGND VPWR sky130_fd_sc_hd__tapvpwrvgnd_1
XFILLER_15_430 VGND VGND VPWR VPWR sky130_fd_sc_hd__fill_1
XFILLER_27_290 VGND VGND VPWR VPWR sky130_fd_sc_hd__decap_3
XFILLER_63_60 VGND VGND VPWR VPWR sky130_fd_sc_hd__decap_3
XTAP_TAPCELL_ROW_17_458 VGND VPWR sky130_fd_sc_hd__tapvpwrvgnd_1
XFILLER_42_271 VGND VGND VPWR VPWR sky130_fd_sc_hd__decap_3
Xclkbuf_3_4__f_clk clkbuf_0_clk/X VGND VGND VPWR VPWR clkbuf_leaf_4_clk/A sky130_fd_sc_hd__clkbuf_16
XTAP_TAPCELL_ROW_45_789 VGND VPWR sky130_fd_sc_hd__tapvpwrvgnd_1
XFILLER_8_11 VGND VGND VPWR VPWR sky130_fd_sc_hd__decap_3
XFILLER_30_477 VGND VGND VPWR VPWR sky130_fd_sc_hd__fill_1
XFILLER_8_44 VGND VGND VPWR VPWR sky130_fd_sc_hd__decap_3
XFILLER_8_77 VGND VGND VPWR VPWR sky130_fd_sc_hd__decap_3
XFILLER_8_88 VGND VGND VPWR VPWR sky130_fd_sc_hd__decap_3
Xwire560 wire562/X VGND VGND VPWR VPWR wire560/X sky130_fd_sc_hd__clkdlybuf4s25_1
X_3510_ _3330_/Y _3383_/B _3442_/B _3362_/A VGND VGND VPWR VPWR _3510_/X sky130_fd_sc_hd__a2bb2o_2
XFILLER_116_516 VGND VGND VPWR VPWR sky130_fd_sc_hd__decap_3
XFILLER_6_150 VGND VGND VPWR VPWR sky130_fd_sc_hd__decap_3
XFILLER_7_673 VGND VGND VPWR VPWR sky130_fd_sc_hd__decap_3
Xhold607 _6860_/Q VGND VGND VPWR VPWR _6860_/D sky130_fd_sc_hd__dlygate4sd3_1
Xhold618 _6954_/Q VGND VGND VPWR VPWR _6954_/D sky130_fd_sc_hd__dlygate4sd3_1
Xhold629 _6774_/Q VGND VGND VPWR VPWR _6774_/D sky130_fd_sc_hd__dlygate4sd3_1
X_3441_ _7058_/Q _3577_/B _3590_/A _3440_/X VGND VGND VPWR VPWR _3544_/A sky130_fd_sc_hd__o211ai_2
XTAP_TAPCELL_ROW_77_1179 VGND VPWR sky130_fd_sc_hd__tapvpwrvgnd_1
XFILLER_40_3 VGND VGND VPWR VPWR sky130_fd_sc_hd__decap_3
XFILLER_69_113 VGND VGND VPWR VPWR sky130_fd_sc_hd__fill_1
X_5111_ _3610_/A _3603_/Y _4292_/C _3548_/X VGND VGND VPWR VPWR _5111_/X sky130_fd_sc_hd__a31o_2
XTAP_TAPCELL_ROW_90_1335 VGND VPWR sky130_fd_sc_hd__tapvpwrvgnd_1
XFILLER_69_146 VGND VGND VPWR VPWR sky130_fd_sc_hd__decap_3
XFILLER_85_617 VGND VGND VPWR VPWR sky130_fd_sc_hd__decap_3
XFILLER_111_287 VGND VGND VPWR VPWR sky130_fd_sc_hd__decap_3
XFILLER_38_533 VGND VGND VPWR VPWR sky130_fd_sc_hd__decap_3
XFILLER_77_190 VGND VGND VPWR VPWR sky130_fd_sc_hd__decap_3
XFILLER_93_650 VGND VGND VPWR VPWR sky130_fd_sc_hd__decap_3
XFILLER_65_352 VGND VGND VPWR VPWR sky130_fd_sc_hd__decap_3
XFILLER_65_396 VGND VGND VPWR VPWR sky130_fd_sc_hd__decap_3
X_6993_ _7369_/CLK _6993_/D _6273_/Y VGND VGND VPWR VPWR _6993_/Q sky130_fd_sc_hd__dfrtp_2
XFILLER_33_293 VGND VGND VPWR VPWR sky130_fd_sc_hd__decap_3
X_4826_ _4826_/A _4826_/B VGND VGND VPWR VPWR _7001_/D sky130_fd_sc_hd__nor2_2
X_4757_ _4757_/A _4665_/X VGND VGND VPWR VPWR _4759_/A sky130_fd_sc_hd__or2b_2
XFILLER_111_9 VGND VGND VPWR VPWR sky130_fd_sc_hd__decap_3
XFILLER_4_109 VGND VGND VPWR VPWR sky130_fd_sc_hd__decap_3
X_4688_ _7001_/Q _7002_/Q _4687_/B _5605_/B VGND VGND VPWR VPWR _4688_/X sky130_fd_sc_hd__a31o_2
X_3708_ _6801_/Q _3759_/A2 _3767_/A2 _6711_/Q _3707_/X VGND VGND VPWR VPWR _3708_/X
+ sky130_fd_sc_hd__a221o_2
XFILLER_108_12 VGND VGND VPWR VPWR sky130_fd_sc_hd__decap_3
X_6427_ _6558_/A VGND VGND VPWR VPWR _6427_/Y sky130_fd_sc_hd__inv_2
X_3639_ _3636_/Y _3548_/X _3505_/X _5020_/A _3638_/X VGND VGND VPWR VPWR _3639_/X
+ sky130_fd_sc_hd__o221a_2
XFILLER_108_56 VGND VGND VPWR VPWR sky130_fd_sc_hd__decap_3
X_6358_ _6385_/A VGND VGND VPWR VPWR _6358_/Y sky130_fd_sc_hd__inv_2
XFILLER_0_337 VGND VGND VPWR VPWR sky130_fd_sc_hd__decap_3
XFILLER_115_582 VGND VGND VPWR VPWR sky130_fd_sc_hd__decap_3
XFILLER_68_38 VGND VGND VPWR VPWR sky130_fd_sc_hd__decap_3
XFILLER_88_433 VGND VGND VPWR VPWR sky130_fd_sc_hd__decap_3
X_6289_ _6388_/A VGND VGND VPWR VPWR _6289_/Y sky130_fd_sc_hd__inv_2
XFILLER_29_522 VGND VGND VPWR VPWR sky130_fd_sc_hd__fill_1
XFILLER_75_105 VGND VGND VPWR VPWR sky130_fd_sc_hd__decap_3
XFILLER_75_116 VGND VGND VPWR VPWR sky130_fd_sc_hd__decap_3
XFILLER_76_628 VGND VGND VPWR VPWR sky130_fd_sc_hd__decap_3
XFILLER_88_488 VGND VGND VPWR VPWR sky130_fd_sc_hd__fill_2
XTAP_TAPCELL_ROW_110_1571 VGND VPWR sky130_fd_sc_hd__tapvpwrvgnd_1
XFILLER_69_691 VGND VGND VPWR VPWR sky130_fd_sc_hd__fill_1
XFILLER_84_15 VGND VGND VPWR VPWR sky130_fd_sc_hd__fill_1
XFILLER_56_374 VGND VGND VPWR VPWR sky130_fd_sc_hd__fill_1
XFILLER_16_227 VGND VGND VPWR VPWR sky130_fd_sc_hd__fill_1
XFILLER_17_42 VGND VGND VPWR VPWR sky130_fd_sc_hd__decap_3
XFILLER_44_536 VGND VGND VPWR VPWR sky130_fd_sc_hd__fill_2
XFILLER_16_249 VGND VGND VPWR VPWR sky130_fd_sc_hd__decap_3
XFILLER_17_97 VGND VGND VPWR VPWR sky130_fd_sc_hd__decap_3
XFILLER_31_208 VGND VGND VPWR VPWR sky130_fd_sc_hd__decap_3
XFILLER_12_400 VGND VGND VPWR VPWR sky130_fd_sc_hd__decap_3
XFILLER_12_411 VGND VGND VPWR VPWR sky130_fd_sc_hd__fill_2
XFILLER_24_271 VGND VGND VPWR VPWR sky130_fd_sc_hd__decap_3
XFILLER_71_388 VGND VGND VPWR VPWR sky130_fd_sc_hd__decap_3
XFILLER_71_399 VGND VGND VPWR VPWR sky130_fd_sc_hd__decap_3
XTAP_TAPCELL_ROW_14_417 VGND VPWR sky130_fd_sc_hd__tapvpwrvgnd_1
XTAP_TAPCELL_ROW_42_759 VGND VPWR sky130_fd_sc_hd__tapvpwrvgnd_1
XFILLER_12_488 VGND VGND VPWR VPWR sky130_fd_sc_hd__fill_1
XFILLER_33_96 VGND VGND VPWR VPWR sky130_fd_sc_hd__decap_3
XFILLER_3_131 VGND VGND VPWR VPWR sky130_fd_sc_hd__decap_3
XFILLER_4_654 VGND VGND VPWR VPWR sky130_fd_sc_hd__decap_3
XFILLER_3_164 VGND VGND VPWR VPWR sky130_fd_sc_hd__decap_3
XFILLER_4_687 VGND VGND VPWR VPWR sky130_fd_sc_hd__decap_3
XFILLER_79_411 VGND VGND VPWR VPWR sky130_fd_sc_hd__decap_3
XFILLER_67_617 VGND VGND VPWR VPWR sky130_fd_sc_hd__fill_1
XFILLER_67_628 VGND VGND VPWR VPWR sky130_fd_sc_hd__decap_3
XFILLER_79_477 VGND VGND VPWR VPWR sky130_fd_sc_hd__decap_3
XFILLER_79_499 VGND VGND VPWR VPWR sky130_fd_sc_hd__decap_3
XFILLER_94_436 VGND VGND VPWR VPWR sky130_fd_sc_hd__decap_3
XFILLER_59_190 VGND VGND VPWR VPWR sky130_fd_sc_hd__decap_3
XFILLER_66_138 VGND VGND VPWR VPWR sky130_fd_sc_hd__fill_2
XFILLER_47_363 VGND VGND VPWR VPWR sky130_fd_sc_hd__decap_3
XFILLER_62_300 VGND VGND VPWR VPWR sky130_fd_sc_hd__decap_3
XFILLER_35_536 VGND VGND VPWR VPWR sky130_fd_sc_hd__decap_3
XFILLER_47_396 VGND VGND VPWR VPWR sky130_fd_sc_hd__decap_3
XFILLER_62_333 VGND VGND VPWR VPWR sky130_fd_sc_hd__decap_3
XFILLER_74_193 VGND VGND VPWR VPWR sky130_fd_sc_hd__decap_3
XFILLER_74_70 VGND VGND VPWR VPWR sky130_fd_sc_hd__decap_3
XFILLER_90_664 VGND VGND VPWR VPWR sky130_fd_sc_hd__decap_3
XFILLER_50_539 VGND VGND VPWR VPWR sky130_fd_sc_hd__fill_2
XFILLER_15_293 VGND VGND VPWR VPWR sky130_fd_sc_hd__decap_3
XFILLER_30_230 VGND VGND VPWR VPWR sky130_fd_sc_hd__decap_3
X_5660_ _5660_/A _5660_/B _5660_/C _5660_/D VGND VGND VPWR VPWR _5661_/D sky130_fd_sc_hd__and4_2
XFILLER_88_3 VGND VGND VPWR VPWR sky130_fd_sc_hd__decap_3
XFILLER_90_91 VGND VGND VPWR VPWR sky130_fd_sc_hd__decap_3
X_4611_ _4611_/A VGND VGND VPWR VPWR _4611_/Y sky130_fd_sc_hd__inv_2
X_5591_ _5591_/A _5595_/B VGND VGND VPWR VPWR _7032_/D sky130_fd_sc_hd__or2_2
X_7330_ _7330_/CLK _7330_/D _6610_/Y VGND VGND VPWR VPWR _7330_/Q sky130_fd_sc_hd__dfrtp_2
X_4542_ _4542_/A _4561_/B VGND VGND VPWR VPWR _7309_/D sky130_fd_sc_hd__and2_2
XFILLER_7_492 VGND VGND VPWR VPWR sky130_fd_sc_hd__decap_3
X_7261_ _7397_/CLK _7261_/D _6541_/Y VGND VGND VPWR VPWR _7261_/Q sky130_fd_sc_hd__dfrtp_2
XFILLER_116_368 VGND VGND VPWR VPWR sky130_fd_sc_hd__decap_3
X_3424_ _3398_/Y _3419_/Y _3424_/S VGND VGND VPWR VPWR _3590_/C sky130_fd_sc_hd__mux2_4
X_7192_ _7322_/CLK _7192_/D _6472_/Y VGND VGND VPWR VPWR _7192_/Q sky130_fd_sc_hd__dfrtp_2
XPHY_EDGE_ROW_115_Right_115 VGND VGND VPWR VPWR sky130_fd_sc_hd__decap_3
XFILLER_112_530 VGND VGND VPWR VPWR sky130_fd_sc_hd__fill_2
XFILLER_58_606 VGND VGND VPWR VPWR sky130_fd_sc_hd__decap_3
XFILLER_97_252 VGND VGND VPWR VPWR sky130_fd_sc_hd__decap_3
X_3355_ _3369_/A _5668_/A _3519_/B VGND VGND VPWR VPWR _3355_/Y sky130_fd_sc_hd__o21ai_2
XFILLER_112_585 VGND VGND VPWR VPWR sky130_fd_sc_hd__decap_3
XFILLER_58_639 VGND VGND VPWR VPWR sky130_fd_sc_hd__decap_3
Xhold1104 _7403_/Q VGND VGND VPWR VPWR _3693_/A0 sky130_fd_sc_hd__dlygate4sd3_1
Xhold1115 _7172_/Q VGND VGND VPWR VPWR _5317_/A0 sky130_fd_sc_hd__dlygate4sd3_1
XFILLER_57_138 VGND VGND VPWR VPWR sky130_fd_sc_hd__decap_3
XFILLER_85_458 VGND VGND VPWR VPWR sky130_fd_sc_hd__decap_3
XFILLER_97_296 VGND VGND VPWR VPWR sky130_fd_sc_hd__decap_3
Xhold1126 _7319_/Q VGND VGND VPWR VPWR _4520_/A0 sky130_fd_sc_hd__dlygate4sd3_1
Xhold1137 _7220_/Q VGND VGND VPWR VPWR _5217_/A sky130_fd_sc_hd__dlygate4sd3_1
Xhold1148 _7393_/Q VGND VGND VPWR VPWR _3770_/A1 sky130_fd_sc_hd__dlygate4sd3_1
X_5025_ _6989_/Q _5044_/A _6990_/Q VGND VGND VPWR VPWR _5026_/B sky130_fd_sc_hd__a21oi_2
XFILLER_38_352 VGND VGND VPWR VPWR sky130_fd_sc_hd__decap_3
XFILLER_66_672 VGND VGND VPWR VPWR sky130_fd_sc_hd__decap_3
Xhold1159 _7145_/Q VGND VGND VPWR VPWR _5375_/A0 sky130_fd_sc_hd__dlygate4sd3_1
XFILLER_26_536 VGND VGND VPWR VPWR sky130_fd_sc_hd__decap_3
XFILLER_38_374 VGND VGND VPWR VPWR sky130_fd_sc_hd__decap_3
XFILLER_53_333 VGND VGND VPWR VPWR sky130_fd_sc_hd__decap_3
XFILLER_54_18 VGND VGND VPWR VPWR sky130_fd_sc_hd__decap_3
XFILLER_54_29 VGND VGND VPWR VPWR sky130_fd_sc_hd__decap_3
XFILLER_81_620 VGND VGND VPWR VPWR sky130_fd_sc_hd__decap_3
XFILLER_65_193 VGND VGND VPWR VPWR sky130_fd_sc_hd__decap_3
XFILLER_80_130 VGND VGND VPWR VPWR sky130_fd_sc_hd__decap_3
XFILLER_80_141 VGND VGND VPWR VPWR sky130_fd_sc_hd__decap_3
XFILLER_81_664 VGND VGND VPWR VPWR sky130_fd_sc_hd__decap_3
X_6976_ _6976_/CLK _6976_/D VGND VGND VPWR VPWR _6976_/Q sky130_fd_sc_hd__dfxtp_2
XFILLER_110_24 VGND VGND VPWR VPWR sky130_fd_sc_hd__decap_3
XFILLER_110_35 VGND VGND VPWR VPWR sky130_fd_sc_hd__decap_3
XFILLER_53_377 VGND VGND VPWR VPWR sky130_fd_sc_hd__fill_1
XFILLER_53_388 VGND VGND VPWR VPWR sky130_fd_sc_hd__decap_3
XFILLER_53_399 VGND VGND VPWR VPWR sky130_fd_sc_hd__decap_3
XFILLER_80_174 VGND VGND VPWR VPWR sky130_fd_sc_hd__decap_3
XFILLER_110_68 VGND VGND VPWR VPWR sky130_fd_sc_hd__decap_3
XFILLER_21_252 VGND VGND VPWR VPWR sky130_fd_sc_hd__decap_3
XFILLER_21_274 VGND VGND VPWR VPWR sky130_fd_sc_hd__decap_3
XFILLER_21_296 VGND VGND VPWR VPWR sky130_fd_sc_hd__decap_3
X_4809_ _7002_/Q _4826_/A VGND VGND VPWR VPWR _7002_/D sky130_fd_sc_hd__xor2_2
XPHY_EDGE_ROW_17_Right_17 VGND VGND VPWR VPWR sky130_fd_sc_hd__decap_3
XFILLER_107_313 VGND VGND VPWR VPWR sky130_fd_sc_hd__decap_3
XFILLER_5_407 VGND VGND VPWR VPWR sky130_fd_sc_hd__decap_3
XFILLER_107_357 VGND VGND VPWR VPWR sky130_fd_sc_hd__decap_3
XFILLER_107_368 VGND VGND VPWR VPWR sky130_fd_sc_hd__decap_3
XTAP_TAPCELL_ROW_112_1600 VGND VPWR sky130_fd_sc_hd__tapvpwrvgnd_1
XFILLER_0_101 VGND VGND VPWR VPWR sky130_fd_sc_hd__decap_3
XFILLER_1_635 VGND VGND VPWR VPWR sky130_fd_sc_hd__decap_3
Xhold982 _7394_/Q VGND VGND VPWR VPWR hold982/X sky130_fd_sc_hd__dlygate4sd3_1
Xhold971 _7320_/Q VGND VGND VPWR VPWR hold971/X sky130_fd_sc_hd__dlygate4sd3_1
Xhold960 _7392_/Q VGND VGND VPWR VPWR hold960/X sky130_fd_sc_hd__dlygate4sd3_1
XFILLER_1_668 VGND VGND VPWR VPWR sky130_fd_sc_hd__decap_3
XFILLER_88_230 VGND VGND VPWR VPWR sky130_fd_sc_hd__decap_3
Xhold993 _7044_/Q VGND VGND VPWR VPWR hold993/X sky130_fd_sc_hd__dlygate4sd3_1
XFILLER_103_585 VGND VGND VPWR VPWR sky130_fd_sc_hd__decap_3
XFILLER_1_679 VGND VGND VPWR VPWR sky130_fd_sc_hd__decap_3
XFILLER_48_105 VGND VGND VPWR VPWR sky130_fd_sc_hd__fill_2
XFILLER_49_617 VGND VGND VPWR VPWR sky130_fd_sc_hd__decap_3
XFILLER_95_47 VGND VGND VPWR VPWR sky130_fd_sc_hd__decap_3
XPHY_EDGE_ROW_26_Right_26 VGND VGND VPWR VPWR sky130_fd_sc_hd__decap_3
XFILLER_48_138 VGND VGND VPWR VPWR sky130_fd_sc_hd__fill_2
XFILLER_76_447 VGND VGND VPWR VPWR sky130_fd_sc_hd__decap_3
XFILLER_76_458 VGND VGND VPWR VPWR sky130_fd_sc_hd__decap_3
XFILLER_95_69 VGND VGND VPWR VPWR sky130_fd_sc_hd__decap_3
XFILLER_28_63 VGND VGND VPWR VPWR sky130_fd_sc_hd__decap_3
XFILLER_57_650 VGND VGND VPWR VPWR sky130_fd_sc_hd__decap_3
XFILLER_63_108 VGND VGND VPWR VPWR sky130_fd_sc_hd__decap_3
XFILLER_76_469 VGND VGND VPWR VPWR sky130_fd_sc_hd__decap_3
XTAP_TAPCELL_ROW_47_818 VGND VPWR sky130_fd_sc_hd__tapvpwrvgnd_1
XFILLER_28_85 VGND VGND VPWR VPWR sky130_fd_sc_hd__decap_3
XFILLER_56_160 VGND VGND VPWR VPWR sky130_fd_sc_hd__decap_3
XFILLER_84_480 VGND VGND VPWR VPWR sky130_fd_sc_hd__decap_3
XFILLER_32_506 VGND VGND VPWR VPWR sky130_fd_sc_hd__decap_3
XFILLER_44_333 VGND VGND VPWR VPWR sky130_fd_sc_hd__decap_3
XTAP_TAPCELL_ROW_63_1009 VGND VPWR sky130_fd_sc_hd__tapvpwrvgnd_1
XTAP_TAPCELL_ROW_27_575 VGND VPWR sky130_fd_sc_hd__tapvpwrvgnd_1
XFILLER_12_230 VGND VGND VPWR VPWR sky130_fd_sc_hd__decap_3
XFILLER_25_591 VGND VGND VPWR VPWR sky130_fd_sc_hd__decap_3
XPHY_EDGE_ROW_35_Right_35 VGND VGND VPWR VPWR sky130_fd_sc_hd__decap_3
XFILLER_40_583 VGND VGND VPWR VPWR sky130_fd_sc_hd__decap_3
XFILLER_60_83 VGND VGND VPWR VPWR sky130_fd_sc_hd__fill_1
XFILLER_8_256 VGND VGND VPWR VPWR sky130_fd_sc_hd__fill_1
XFILLER_5_12 VGND VGND VPWR VPWR sky130_fd_sc_hd__decap_3
XFILLER_60_94 VGND VGND VPWR VPWR sky130_fd_sc_hd__fill_1
XFILLER_8_289 VGND VGND VPWR VPWR sky130_fd_sc_hd__decap_3
Xoutput509 _5648_/A VGND VGND VPWR VPWR instruction_out[27] sky130_fd_sc_hd__clkdlybuf4s25_1
XFILLER_113_305 VGND VGND VPWR VPWR sky130_fd_sc_hd__decap_3
XFILLER_5_45 VGND VGND VPWR VPWR sky130_fd_sc_hd__decap_3
XFILLER_4_473 VGND VGND VPWR VPWR sky130_fd_sc_hd__decap_3
XFILLER_5_78 VGND VGND VPWR VPWR sky130_fd_sc_hd__decap_3
XTAP_TAPCELL_ROW_74_1138 VGND VPWR sky130_fd_sc_hd__tapvpwrvgnd_1
XFILLER_113_349 VGND VGND VPWR VPWR sky130_fd_sc_hd__decap_3
XFILLER_69_81 VGND VGND VPWR VPWR sky130_fd_sc_hd__decap_3
XPHY_EDGE_ROW_44_Right_44 VGND VGND VPWR VPWR sky130_fd_sc_hd__decap_3
XFILLER_39_105 VGND VGND VPWR VPWR sky130_fd_sc_hd__decap_3
XFILLER_39_116 VGND VGND VPWR VPWR sky130_fd_sc_hd__decap_3
XFILLER_67_414 VGND VGND VPWR VPWR sky130_fd_sc_hd__decap_3
XFILLER_79_274 VGND VGND VPWR VPWR sky130_fd_sc_hd__decap_3
XFILLER_39_149 VGND VGND VPWR VPWR sky130_fd_sc_hd__decap_3
XFILLER_67_447 VGND VGND VPWR VPWR sky130_fd_sc_hd__fill_1
XFILLER_79_296 VGND VGND VPWR VPWR sky130_fd_sc_hd__decap_3
XFILLER_48_672 VGND VGND VPWR VPWR sky130_fd_sc_hd__decap_3
XFILLER_55_609 VGND VGND VPWR VPWR sky130_fd_sc_hd__decap_3
XFILLER_67_469 VGND VGND VPWR VPWR sky130_fd_sc_hd__decap_3
XFILLER_94_277 VGND VGND VPWR VPWR sky130_fd_sc_hd__decap_3
XFILLER_63_620 VGND VGND VPWR VPWR sky130_fd_sc_hd__decap_3
XFILLER_75_491 VGND VGND VPWR VPWR sky130_fd_sc_hd__decap_3
XFILLER_94_299 VGND VGND VPWR VPWR sky130_fd_sc_hd__decap_3
XFILLER_62_141 VGND VGND VPWR VPWR sky130_fd_sc_hd__decap_3
XFILLER_63_653 VGND VGND VPWR VPWR sky130_fd_sc_hd__decap_3
X_6830_ _6977_/CLK _6830_/D VGND VGND VPWR VPWR _6830_/Q sky130_fd_sc_hd__dfxtp_2
XFILLER_35_399 VGND VGND VPWR VPWR sky130_fd_sc_hd__decap_3
XFILLER_62_163 VGND VGND VPWR VPWR sky130_fd_sc_hd__decap_3
X_6761_ _6977_/CLK _6761_/D VGND VGND VPWR VPWR _6761_/Q sky130_fd_sc_hd__dfxtp_2
XTAP_TAPCELL_ROW_85_1267 VGND VPWR sky130_fd_sc_hd__tapvpwrvgnd_1
X_5712_ _7362_/Q hold906/X _5719_/S VGND VGND VPWR VPWR _6706_/D sky130_fd_sc_hd__mux2_2
X_3973_ _7354_/Q _4515_/A0 _3973_/S VGND VGND VPWR VPWR _7354_/D sky130_fd_sc_hd__mux2_2
XPHY_EDGE_ROW_53_Right_53 VGND VGND VPWR VPWR sky130_fd_sc_hd__decap_3
X_6692_ clkload4/A _6692_/D VGND VGND VPWR VPWR _6692_/Q sky130_fd_sc_hd__dfxtp_2
X_5643_ _5643_/A VGND VGND VPWR VPWR _5643_/X sky130_fd_sc_hd__buf_1
X_5574_ hold952/X _4960_/A _4983_/X VGND VGND VPWR VPWR _7043_/D sky130_fd_sc_hd__a21o_2
X_7313_ _7322_/CLK _7313_/D _6593_/Y VGND VGND VPWR VPWR _7313_/Q sky130_fd_sc_hd__dfrtp_2
XFILLER_116_132 VGND VGND VPWR VPWR sky130_fd_sc_hd__decap_3
X_7244_ _7374_/CLK _7244_/D _6524_/Y VGND VGND VPWR VPWR _7244_/Q sky130_fd_sc_hd__dfrtp_2
X_4456_ _4456_/A _4054_/A VGND VGND VPWR VPWR _4456_/X sky130_fd_sc_hd__or2b_2
XPHY_EDGE_ROW_62_Right_62 VGND VGND VPWR VPWR sky130_fd_sc_hd__decap_3
X_7175_ _7369_/CLK _7175_/D _6455_/Y VGND VGND VPWR VPWR _7175_/Q sky130_fd_sc_hd__dfrtp_2
X_4387_ _7241_/Q _4430_/A2 _4430_/B1 _7177_/Q _4386_/X VGND VGND VPWR VPWR _4387_/X
+ sky130_fd_sc_hd__a221o_2
X_3407_ _3421_/B _3421_/C _3417_/C VGND VGND VPWR VPWR _3407_/X sky130_fd_sc_hd__and3_2
XFILLER_105_24 VGND VGND VPWR VPWR sky130_fd_sc_hd__decap_3
XFILLER_98_561 VGND VGND VPWR VPWR sky130_fd_sc_hd__decap_3
XFILLER_100_522 VGND VGND VPWR VPWR sky130_fd_sc_hd__decap_3
XFILLER_46_609 VGND VGND VPWR VPWR sky130_fd_sc_hd__decap_3
XFILLER_73_417 VGND VGND VPWR VPWR sky130_fd_sc_hd__fill_2
XFILLER_38_171 VGND VGND VPWR VPWR sky130_fd_sc_hd__decap_3
XFILLER_54_631 VGND VGND VPWR VPWR sky130_fd_sc_hd__decap_3
XFILLER_73_439 VGND VGND VPWR VPWR sky130_fd_sc_hd__decap_3
X_5008_ _4680_/A _5015_/B _4960_/A VGND VGND VPWR VPWR _5009_/B sky130_fd_sc_hd__a21o_2
XFILLER_26_333 VGND VGND VPWR VPWR sky130_fd_sc_hd__decap_3
XFILLER_53_130 VGND VGND VPWR VPWR sky130_fd_sc_hd__fill_2
XFILLER_14_539 VGND VGND VPWR VPWR sky130_fd_sc_hd__decap_3
XFILLER_41_314 VGND VGND VPWR VPWR sky130_fd_sc_hd__decap_3
XFILLER_53_163 VGND VGND VPWR VPWR sky130_fd_sc_hd__decap_3
XFILLER_54_675 VGND VGND VPWR VPWR sky130_fd_sc_hd__decap_3
XFILLER_81_27 VGND VGND VPWR VPWR sky130_fd_sc_hd__decap_3
XPHY_EDGE_ROW_71_Right_71 VGND VGND VPWR VPWR sky130_fd_sc_hd__decap_3
XFILLER_41_358 VGND VGND VPWR VPWR sky130_fd_sc_hd__decap_3
X_6959_ _6959_/CLK _6959_/D VGND VGND VPWR VPWR _6959_/Q sky130_fd_sc_hd__dfxtp_2
XTAP_TAPCELL_ROW_24_545 VGND VPWR sky130_fd_sc_hd__tapvpwrvgnd_1
XTAP_TAPCELL_ROW_24_534 VGND VPWR sky130_fd_sc_hd__tapvpwrvgnd_1
XFILLER_14_21 VGND VGND VPWR VPWR sky130_fd_sc_hd__decap_3
XFILLER_14_32 VGND VGND VPWR VPWR sky130_fd_sc_hd__decap_3
XTAP_TAPCELL_ROW_52_876 VGND VPWR sky130_fd_sc_hd__tapvpwrvgnd_1
XFILLER_30_20 VGND VGND VPWR VPWR sky130_fd_sc_hd__decap_3
XPHY_EDGE_ROW_15_Left_132 VGND VGND VPWR VPWR sky130_fd_sc_hd__decap_3
XFILLER_107_132 VGND VGND VPWR VPWR sky130_fd_sc_hd__decap_3
XFILLER_108_666 VGND VGND VPWR VPWR sky130_fd_sc_hd__decap_3
XPHY_EDGE_ROW_80_Right_80 VGND VGND VPWR VPWR sky130_fd_sc_hd__decap_3
XFILLER_107_187 VGND VGND VPWR VPWR sky130_fd_sc_hd__decap_3
XFILLER_1_443 VGND VGND VPWR VPWR sky130_fd_sc_hd__decap_3
Xhold790 _6730_/Q VGND VGND VPWR VPWR _6730_/D sky130_fd_sc_hd__dlygate4sd3_1
XFILLER_89_561 VGND VGND VPWR VPWR sky130_fd_sc_hd__decap_3
XFILLER_103_371 VGND VGND VPWR VPWR sky130_fd_sc_hd__decap_3
XFILLER_103_393 VGND VGND VPWR VPWR sky130_fd_sc_hd__decap_3
XFILLER_39_73 VGND VGND VPWR VPWR sky130_fd_sc_hd__fill_2
XFILLER_39_84 VGND VGND VPWR VPWR sky130_fd_sc_hd__decap_3
XFILLER_49_436 VGND VGND VPWR VPWR sky130_fd_sc_hd__decap_3
XFILLER_49_447 VGND VGND VPWR VPWR sky130_fd_sc_hd__fill_1
XFILLER_36_108 VGND VGND VPWR VPWR sky130_fd_sc_hd__decap_3
XFILLER_45_620 VGND VGND VPWR VPWR sky130_fd_sc_hd__decap_3
XFILLER_91_214 VGND VGND VPWR VPWR sky130_fd_sc_hd__fill_1
XPHY_EDGE_ROW_24_Left_141 VGND VGND VPWR VPWR sky130_fd_sc_hd__decap_3
XFILLER_29_193 VGND VGND VPWR VPWR sky130_fd_sc_hd__decap_3
XFILLER_44_141 VGND VGND VPWR VPWR sky130_fd_sc_hd__fill_1
XFILLER_45_653 VGND VGND VPWR VPWR sky130_fd_sc_hd__decap_3
XFILLER_55_72 VGND VGND VPWR VPWR sky130_fd_sc_hd__decap_3
XFILLER_57_491 VGND VGND VPWR VPWR sky130_fd_sc_hd__fill_2
XFILLER_72_450 VGND VGND VPWR VPWR sky130_fd_sc_hd__decap_3
XFILLER_91_258 VGND VGND VPWR VPWR sky130_fd_sc_hd__fill_1
XFILLER_32_303 VGND VGND VPWR VPWR sky130_fd_sc_hd__decap_3
XFILLER_32_314 VGND VGND VPWR VPWR sky130_fd_sc_hd__decap_3
XFILLER_44_163 VGND VGND VPWR VPWR sky130_fd_sc_hd__decap_3
XFILLER_60_601 VGND VGND VPWR VPWR sky130_fd_sc_hd__decap_3
XFILLER_17_399 VGND VGND VPWR VPWR sky130_fd_sc_hd__decap_3
XFILLER_44_185 VGND VGND VPWR VPWR sky130_fd_sc_hd__decap_3
XFILLER_60_634 VGND VGND VPWR VPWR sky130_fd_sc_hd__decap_3
XFILLER_60_645 VGND VGND VPWR VPWR sky130_fd_sc_hd__decap_3
XFILLER_20_509 VGND VGND VPWR VPWR sky130_fd_sc_hd__decap_3
XFILLER_32_358 VGND VGND VPWR VPWR sky130_fd_sc_hd__decap_3
XFILLER_60_678 VGND VGND VPWR VPWR sky130_fd_sc_hd__decap_3
XFILLER_13_572 VGND VGND VPWR VPWR sky130_fd_sc_hd__decap_3
XFILLER_13_583 VGND VGND VPWR VPWR sky130_fd_sc_hd__decap_3
XFILLER_40_380 VGND VGND VPWR VPWR sky130_fd_sc_hd__decap_3
XFILLER_71_71 VGND VGND VPWR VPWR sky130_fd_sc_hd__decap_3
XFILLER_72_6 VGND VGND VPWR VPWR sky130_fd_sc_hd__decap_3
XPHY_EDGE_ROW_33_Left_150 VGND VGND VPWR VPWR sky130_fd_sc_hd__decap_3
XFILLER_9_576 VGND VGND VPWR VPWR sky130_fd_sc_hd__fill_1
XFILLER_113_102 VGND VGND VPWR VPWR sky130_fd_sc_hd__decap_3
XFILLER_113_113 VGND VGND VPWR VPWR sky130_fd_sc_hd__decap_3
XFILLER_114_625 VGND VGND VPWR VPWR sky130_fd_sc_hd__decap_3
X_5290_ _5290_/A0 _5156_/X _5292_/S VGND VGND VPWR VPWR _7184_/D sky130_fd_sc_hd__mux2_2
X_4310_ _7352_/Q _3449_/X _3409_/X _7160_/Q VGND VGND VPWR VPWR _4311_/C sky130_fd_sc_hd__a22o_2
XFILLER_99_314 VGND VGND VPWR VPWR sky130_fd_sc_hd__fill_2
XFILLER_113_146 VGND VGND VPWR VPWR sky130_fd_sc_hd__decap_3
XFILLER_114_669 VGND VGND VPWR VPWR sky130_fd_sc_hd__decap_3
X_4241_ _5018_/B _4241_/B VGND VGND VPWR VPWR _5032_/A sky130_fd_sc_hd__or2_2
XFILLER_99_369 VGND VGND VPWR VPWR sky130_fd_sc_hd__decap_3
XFILLER_101_308 VGND VGND VPWR VPWR sky130_fd_sc_hd__decap_3
XFILLER_67_222 VGND VGND VPWR VPWR sky130_fd_sc_hd__fill_2
X_4172_ _4938_/B _4379_/B VGND VGND VPWR VPWR _4936_/A sky130_fd_sc_hd__nor2_2
XFILLER_67_244 VGND VGND VPWR VPWR sky130_fd_sc_hd__decap_3
XFILLER_95_564 VGND VGND VPWR VPWR sky130_fd_sc_hd__decap_3
XFILLER_48_480 VGND VGND VPWR VPWR sky130_fd_sc_hd__decap_3
XFILLER_82_203 VGND VGND VPWR VPWR sky130_fd_sc_hd__decap_3
XFILLER_36_642 VGND VGND VPWR VPWR sky130_fd_sc_hd__fill_2
XFILLER_82_236 VGND VGND VPWR VPWR sky130_fd_sc_hd__decap_3
XFILLER_35_152 VGND VGND VPWR VPWR sky130_fd_sc_hd__decap_3
XFILLER_51_601 VGND VGND VPWR VPWR sky130_fd_sc_hd__decap_3
XFILLER_51_623 VGND VGND VPWR VPWR sky130_fd_sc_hd__decap_3
XFILLER_35_196 VGND VGND VPWR VPWR sky130_fd_sc_hd__decap_3
XFILLER_50_100 VGND VGND VPWR VPWR sky130_fd_sc_hd__decap_3
XFILLER_51_656 VGND VGND VPWR VPWR sky130_fd_sc_hd__decap_3
Xplace450 _3332_/B VGND VGND VPWR VPWR _3318_/B sky130_fd_sc_hd__buf_2
X_6813_ _6911_/CLK _6813_/D VGND VGND VPWR VPWR _6813_/Q sky130_fd_sc_hd__dfxtp_2
X_6744_ _6911_/CLK _6744_/D VGND VGND VPWR VPWR _6744_/Q sky130_fd_sc_hd__dfxtp_2
X_3956_ _7362_/Q _4499_/A0 _3962_/S VGND VGND VPWR VPWR _7362_/D sky130_fd_sc_hd__mux2_2
XFILLER_50_177 VGND VGND VPWR VPWR sky130_fd_sc_hd__decap_3
X_6675_ _6675_/A VGND VGND VPWR VPWR _6675_/Y sky130_fd_sc_hd__inv_2
XTAP_TAPCELL_ROW_21_504 VGND VPWR sky130_fd_sc_hd__tapvpwrvgnd_1
XFILLER_109_408 VGND VGND VPWR VPWR sky130_fd_sc_hd__decap_3
X_5626_ _5626_/A _5634_/B VGND VGND VPWR VPWR _7015_/D sky130_fd_sc_hd__and2_2
X_3887_ _6694_/Q _3906_/B1 _3917_/B1 _6872_/Q _3886_/X VGND VGND VPWR VPWR _3887_/X
+ sky130_fd_sc_hd__a221o_2
XTAP_TAPCELL_ROW_98_1425 VGND VPWR sky130_fd_sc_hd__tapvpwrvgnd_1
XFILLER_105_658 VGND VGND VPWR VPWR sky130_fd_sc_hd__decap_3
XFILLER_4_9 VGND VGND VPWR VPWR sky130_fd_sc_hd__decap_3
X_7227_ clkload6/A _7227_/D _6507_/Y VGND VGND VPWR VPWR _7227_/Q sky130_fd_sc_hd__dfrtp_2
X_4439_ _4440_/A _4650_/B VGND VGND VPWR VPWR _4813_/B sky130_fd_sc_hd__or2_2
XFILLER_58_200 VGND VGND VPWR VPWR sky130_fd_sc_hd__decap_3
XFILLER_58_233 VGND VGND VPWR VPWR sky130_fd_sc_hd__decap_3
XFILLER_76_27 VGND VGND VPWR VPWR sky130_fd_sc_hd__fill_1
XFILLER_86_531 VGND VGND VPWR VPWR sky130_fd_sc_hd__fill_1
X_7158_ clkload7/A _7158_/D _6438_/Y VGND VGND VPWR VPWR _7158_/Q sky130_fd_sc_hd__dfrtp_2
XFILLER_98_380 VGND VGND VPWR VPWR sky130_fd_sc_hd__decap_3
XFILLER_100_330 VGND VGND VPWR VPWR sky130_fd_sc_hd__fill_1
XFILLER_46_406 VGND VGND VPWR VPWR sky130_fd_sc_hd__decap_3
X_7089_ _7322_/CLK _7089_/D _6369_/Y VGND VGND VPWR VPWR _7089_/Q sky130_fd_sc_hd__dfstp_2
XFILLER_58_299 VGND VGND VPWR VPWR sky130_fd_sc_hd__decap_3
XFILLER_73_225 VGND VGND VPWR VPWR sky130_fd_sc_hd__decap_3
XTAP_TAPCELL_ROW_57_935 VGND VPWR sky130_fd_sc_hd__tapvpwrvgnd_1
XTAP_TAPCELL_ROW_29_604 VGND VPWR sky130_fd_sc_hd__tapvpwrvgnd_1
XFILLER_27_653 VGND VGND VPWR VPWR sky130_fd_sc_hd__fill_1
XFILLER_73_258 VGND VGND VPWR VPWR sky130_fd_sc_hd__decap_3
XFILLER_73_269 VGND VGND VPWR VPWR sky130_fd_sc_hd__decap_3
XFILLER_92_15 VGND VGND VPWR VPWR sky130_fd_sc_hd__decap_3
XTAP_TAPCELL_ROW_107_1532 VGND VPWR sky130_fd_sc_hd__tapvpwrvgnd_1
XFILLER_26_141 VGND VGND VPWR VPWR sky130_fd_sc_hd__decap_3
XTAP_TAPCELL_ROW_1_262 VGND VPWR sky130_fd_sc_hd__tapvpwrvgnd_1
XFILLER_14_336 VGND VGND VPWR VPWR sky130_fd_sc_hd__decap_3
XFILLER_25_53 VGND VGND VPWR VPWR sky130_fd_sc_hd__decap_3
XFILLER_26_174 VGND VGND VPWR VPWR sky130_fd_sc_hd__decap_3
XFILLER_41_111 VGND VGND VPWR VPWR sky130_fd_sc_hd__fill_1
XFILLER_42_634 VGND VGND VPWR VPWR sky130_fd_sc_hd__decap_3
XFILLER_42_645 VGND VGND VPWR VPWR sky130_fd_sc_hd__decap_3
XTAP_TAPCELL_ROW_37_692 VGND VPWR sky130_fd_sc_hd__tapvpwrvgnd_1
XFILLER_41_166 VGND VGND VPWR VPWR sky130_fd_sc_hd__fill_2
XFILLER_42_678 VGND VGND VPWR VPWR sky130_fd_sc_hd__decap_3
XFILLER_10_553 VGND VGND VPWR VPWR sky130_fd_sc_hd__decap_3
XFILLER_41_41 VGND VGND VPWR VPWR sky130_fd_sc_hd__decap_3
XFILLER_41_63 VGND VGND VPWR VPWR sky130_fd_sc_hd__decap_3
XFILLER_41_74 VGND VGND VPWR VPWR sky130_fd_sc_hd__decap_3
XTAP_TAPCELL_ROW_71_1108 VGND VPWR sky130_fd_sc_hd__tapvpwrvgnd_1
XFILLER_111_606 VGND VGND VPWR VPWR sky130_fd_sc_hd__decap_3
XFILLER_111_617 VGND VGND VPWR VPWR sky130_fd_sc_hd__decap_3
XFILLER_37_9 VGND VGND VPWR VPWR sky130_fd_sc_hd__decap_3
XTAP_TAPCELL_ROW_9_362 VGND VPWR sky130_fd_sc_hd__tapvpwrvgnd_1
XFILLER_110_116 VGND VGND VPWR VPWR sky130_fd_sc_hd__decap_3
XFILLER_2_35 VGND VGND VPWR VPWR sky130_fd_sc_hd__decap_3
XFILLER_49_222 VGND VGND VPWR VPWR sky130_fd_sc_hd__fill_2
XFILLER_77_520 VGND VGND VPWR VPWR sky130_fd_sc_hd__decap_3
XFILLER_89_391 VGND VGND VPWR VPWR sky130_fd_sc_hd__fill_1
XFILLER_103_190 VGND VGND VPWR VPWR sky130_fd_sc_hd__decap_3
XFILLER_2_68 VGND VGND VPWR VPWR sky130_fd_sc_hd__decap_3
XFILLER_49_255 VGND VGND VPWR VPWR sky130_fd_sc_hd__decap_3
XFILLER_77_553 VGND VGND VPWR VPWR sky130_fd_sc_hd__decap_3
XFILLER_77_564 VGND VGND VPWR VPWR sky130_fd_sc_hd__fill_2
XFILLER_92_501 VGND VGND VPWR VPWR sky130_fd_sc_hd__decap_3
XFILLER_64_225 VGND VGND VPWR VPWR sky130_fd_sc_hd__decap_3
XFILLER_77_597 VGND VGND VPWR VPWR sky130_fd_sc_hd__decap_3
XFILLER_64_247 VGND VGND VPWR VPWR sky130_fd_sc_hd__decap_3
XFILLER_92_567 VGND VGND VPWR VPWR sky130_fd_sc_hd__decap_3
XFILLER_17_141 VGND VGND VPWR VPWR sky130_fd_sc_hd__decap_3
XFILLER_33_612 VGND VGND VPWR VPWR sky130_fd_sc_hd__decap_3
XFILLER_64_269 VGND VGND VPWR VPWR sky130_fd_sc_hd__fill_1
XFILLER_92_589 VGND VGND VPWR VPWR sky130_fd_sc_hd__decap_3
XFILLER_17_196 VGND VGND VPWR VPWR sky130_fd_sc_hd__decap_3
XFILLER_32_111 VGND VGND VPWR VPWR sky130_fd_sc_hd__decap_3
XFILLER_33_656 VGND VGND VPWR VPWR sky130_fd_sc_hd__decap_3
XTAP_TAPCELL_ROW_82_1237 VGND VPWR sky130_fd_sc_hd__tapvpwrvgnd_1
XFILLER_32_144 VGND VGND VPWR VPWR sky130_fd_sc_hd__decap_3
XFILLER_32_155 VGND VGND VPWR VPWR sky130_fd_sc_hd__decap_3
XFILLER_33_667 VGND VGND VPWR VPWR sky130_fd_sc_hd__decap_3
X_4790_ _4781_/X _4782_/Y _4787_/Y _4948_/A _4789_/X VGND VGND VPWR VPWR _5664_/A
+ sky130_fd_sc_hd__o221a_2
X_3810_ _6846_/Q _3892_/A2 _3889_/B1 _6831_/Q _3809_/X VGND VGND VPWR VPWR _3810_/X
+ sky130_fd_sc_hd__a221o_2
X_3741_ _3746_/A _3741_/B _3746_/C VGND VGND VPWR VPWR _3741_/X sky130_fd_sc_hd__and3_4
XFILLER_13_380 VGND VGND VPWR VPWR sky130_fd_sc_hd__decap_3
XFILLER_70_3 VGND VGND VPWR VPWR sky130_fd_sc_hd__decap_3
X_6460_ _6558_/A VGND VGND VPWR VPWR _6460_/Y sky130_fd_sc_hd__inv_2
X_3672_ _3746_/A _3746_/B _3733_/C VGND VGND VPWR VPWR _3672_/X sky130_fd_sc_hd__or3_2
X_6391_ _6553_/A VGND VGND VPWR VPWR _6391_/Y sky130_fd_sc_hd__inv_2
X_5411_ _5411_/A0 _5094_/X _5429_/S VGND VGND VPWR VPWR _7128_/D sky130_fd_sc_hd__mux2_2
XFILLER_114_411 VGND VGND VPWR VPWR sky130_fd_sc_hd__fill_2
X_5342_ _7160_/Q _5094_/X _5350_/S VGND VGND VPWR VPWR _7160_/D sky130_fd_sc_hd__mux2_2
XTAP_TAPCELL_ROW_93_1366 VGND VPWR sky130_fd_sc_hd__tapvpwrvgnd_1
XFILLER_114_477 VGND VGND VPWR VPWR sky130_fd_sc_hd__decap_3
X_7012_ _7386_/CLK _7012_/D _6292_/Y VGND VGND VPWR VPWR _7012_/Q sky130_fd_sc_hd__dfrtp_2
X_4224_ _4371_/A _4371_/B _4224_/C VGND VGND VPWR VPWR _4372_/A sky130_fd_sc_hd__and3_2
XFILLER_68_575 VGND VGND VPWR VPWR sky130_fd_sc_hd__decap_3
X_4155_ _4151_/X _4154_/X _4425_/A VGND VGND VPWR VPWR _4205_/C sky130_fd_sc_hd__o21ai_2
XFILLER_110_672 VGND VGND VPWR VPWR sky130_fd_sc_hd__decap_3
XFILLER_83_534 VGND VGND VPWR VPWR sky130_fd_sc_hd__decap_3
XFILLER_95_372 VGND VGND VPWR VPWR sky130_fd_sc_hd__decap_3
XFILLER_55_236 VGND VGND VPWR VPWR sky130_fd_sc_hd__decap_3
XFILLER_83_556 VGND VGND VPWR VPWR sky130_fd_sc_hd__decap_3
X_4086_ _7270_/Q _4408_/A2 _3949_/S _7334_/Q _4085_/X VGND VGND VPWR VPWR _4086_/X
+ sky130_fd_sc_hd__a221o_2
XFILLER_36_461 VGND VGND VPWR VPWR sky130_fd_sc_hd__decap_3
XFILLER_55_269 VGND VGND VPWR VPWR sky130_fd_sc_hd__decap_3
XFILLER_70_206 VGND VGND VPWR VPWR sky130_fd_sc_hd__decap_3
XTAP_TAPCELL_ROW_54_905 VGND VPWR sky130_fd_sc_hd__tapvpwrvgnd_1
XFILLER_102_58 VGND VGND VPWR VPWR sky130_fd_sc_hd__decap_3
XFILLER_51_420 VGND VGND VPWR VPWR sky130_fd_sc_hd__decap_3
XFILLER_70_228 VGND VGND VPWR VPWR sky130_fd_sc_hd__fill_2
XFILLER_24_656 VGND VGND VPWR VPWR sky130_fd_sc_hd__decap_3
XFILLER_62_29 VGND VGND VPWR VPWR sky130_fd_sc_hd__decap_3
Xplace291 _3913_/A2 VGND VGND VPWR VPWR _3883_/A2 sky130_fd_sc_hd__buf_2
Xplace280 _3892_/A2 VGND VGND VPWR VPWR _3884_/A2 sky130_fd_sc_hd__buf_2
XFILLER_11_317 VGND VGND VPWR VPWR sky130_fd_sc_hd__decap_3
XFILLER_23_166 VGND VGND VPWR VPWR sky130_fd_sc_hd__fill_2
X_4988_ _4988_/A _4988_/B VGND VGND VPWR VPWR _5004_/A sky130_fd_sc_hd__nor2_2
XTAP_TAPCELL_ROW_62_993 VGND VPWR sky130_fd_sc_hd__tapvpwrvgnd_1
XTAP_TAPCELL_ROW_34_662 VGND VPWR sky130_fd_sc_hd__tapvpwrvgnd_1
XTAP_TAPCELL_ROW_102_1473 VGND VPWR sky130_fd_sc_hd__tapvpwrvgnd_1
XFILLER_109_205 VGND VGND VPWR VPWR sky130_fd_sc_hd__decap_3
X_6727_ _6972_/CLK _6727_/D VGND VGND VPWR VPWR _6727_/Q sky130_fd_sc_hd__dfxtp_2
X_3939_ _7370_/Q _7338_/Q _3947_/S VGND VGND VPWR VPWR _7370_/D sky130_fd_sc_hd__mux2_2
X_6658_ _6660_/A VGND VGND VPWR VPWR _6658_/Y sky130_fd_sc_hd__inv_2
XFILLER_11_33 VGND VGND VPWR VPWR sky130_fd_sc_hd__decap_3
X_5609_ _5609_/A _5633_/B VGND VGND VPWR VPWR _7023_/D sky130_fd_sc_hd__or2_2
XFILLER_105_411 VGND VGND VPWR VPWR sky130_fd_sc_hd__decap_3
XFILLER_11_66 VGND VGND VPWR VPWR sky130_fd_sc_hd__decap_3
X_6589_ _6651_/A VGND VGND VPWR VPWR _6589_/Y sky130_fd_sc_hd__inv_2
XFILLER_105_444 VGND VGND VPWR VPWR sky130_fd_sc_hd__decap_3
XFILLER_11_88 VGND VGND VPWR VPWR sky130_fd_sc_hd__decap_3
XFILLER_87_15 VGND VGND VPWR VPWR sky130_fd_sc_hd__decap_3
XFILLER_78_306 VGND VGND VPWR VPWR sky130_fd_sc_hd__fill_2
XFILLER_78_339 VGND VGND VPWR VPWR sky130_fd_sc_hd__decap_3
XTAP_TAPCELL_ROW_6_321 VGND VPWR sky130_fd_sc_hd__tapvpwrvgnd_1
XFILLER_59_553 VGND VGND VPWR VPWR sky130_fd_sc_hd__decap_3
XFILLER_86_350 VGND VGND VPWR VPWR sky130_fd_sc_hd__decap_3
XFILLER_46_203 VGND VGND VPWR VPWR sky130_fd_sc_hd__decap_3
XFILLER_59_586 VGND VGND VPWR VPWR sky130_fd_sc_hd__decap_3
XFILLER_74_512 VGND VGND VPWR VPWR sky130_fd_sc_hd__decap_3
XFILLER_86_383 VGND VGND VPWR VPWR sky130_fd_sc_hd__decap_3
XFILLER_100_171 VGND VGND VPWR VPWR sky130_fd_sc_hd__decap_3
XFILLER_27_461 VGND VGND VPWR VPWR sky130_fd_sc_hd__decap_3
XFILLER_34_409 VGND VGND VPWR VPWR sky130_fd_sc_hd__decap_3
XFILLER_36_52 VGND VGND VPWR VPWR sky130_fd_sc_hd__decap_3
XFILLER_61_217 VGND VGND VPWR VPWR sky130_fd_sc_hd__decap_3
XFILLER_74_589 VGND VGND VPWR VPWR sky130_fd_sc_hd__decap_3
XFILLER_27_494 VGND VGND VPWR VPWR sky130_fd_sc_hd__decap_3
XFILLER_36_85 VGND VGND VPWR VPWR sky130_fd_sc_hd__decap_3
XFILLER_42_431 VGND VGND VPWR VPWR sky130_fd_sc_hd__decap_3
XFILLER_54_280 VGND VGND VPWR VPWR sky130_fd_sc_hd__decap_3
XFILLER_61_228 VGND VGND VPWR VPWR sky130_fd_sc_hd__decap_3
XTAP_TAPCELL_ROW_68_1070 VGND VPWR sky130_fd_sc_hd__tapvpwrvgnd_1
XFILLER_14_144 VGND VGND VPWR VPWR sky130_fd_sc_hd__decap_3
XFILLER_15_667 VGND VGND VPWR VPWR sky130_fd_sc_hd__decap_3
XFILLER_14_188 VGND VGND VPWR VPWR sky130_fd_sc_hd__decap_3
XFILLER_42_475 VGND VGND VPWR VPWR sky130_fd_sc_hd__fill_1
XFILLER_52_51 VGND VGND VPWR VPWR sky130_fd_sc_hd__decap_3
XFILLER_52_73 VGND VGND VPWR VPWR sky130_fd_sc_hd__decap_3
XFILLER_6_321 VGND VGND VPWR VPWR sky130_fd_sc_hd__decap_3
XFILLER_115_208 VGND VGND VPWR VPWR sky130_fd_sc_hd__decap_3
XFILLER_6_365 VGND VGND VPWR VPWR sky130_fd_sc_hd__decap_3
XFILLER_6_387 VGND VGND VPWR VPWR sky130_fd_sc_hd__fill_2
XFILLER_6_398 VGND VGND VPWR VPWR sky130_fd_sc_hd__decap_3
XFILLER_35_6 VGND VGND VPWR VPWR sky130_fd_sc_hd__fill_1
XFILLER_97_648 VGND VGND VPWR VPWR sky130_fd_sc_hd__decap_3
XFILLER_111_458 VGND VGND VPWR VPWR sky130_fd_sc_hd__fill_1
XFILLER_84_309 VGND VGND VPWR VPWR sky130_fd_sc_hd__decap_3
XFILLER_96_147 VGND VGND VPWR VPWR sky130_fd_sc_hd__decap_3
XFILLER_37_214 VGND VGND VPWR VPWR sky130_fd_sc_hd__decap_3
XFILLER_77_92 VGND VGND VPWR VPWR sky130_fd_sc_hd__decap_3
XFILLER_25_409 VGND VGND VPWR VPWR sky130_fd_sc_hd__decap_3
XFILLER_65_567 VGND VGND VPWR VPWR sky130_fd_sc_hd__decap_3
XFILLER_80_515 VGND VGND VPWR VPWR sky130_fd_sc_hd__decap_3
XFILLER_18_483 VGND VGND VPWR VPWR sky130_fd_sc_hd__decap_3
XFILLER_33_420 VGND VGND VPWR VPWR sky130_fd_sc_hd__decap_3
XFILLER_52_239 VGND VGND VPWR VPWR sky130_fd_sc_hd__fill_2
XFILLER_80_548 VGND VGND VPWR VPWR sky130_fd_sc_hd__decap_3
X_4911_ _6997_/Q _4931_/A VGND VGND VPWR VPWR _4912_/B sky130_fd_sc_hd__nor2_2
XFILLER_20_103 VGND VGND VPWR VPWR sky130_fd_sc_hd__fill_2
XFILLER_21_637 VGND VGND VPWR VPWR sky130_fd_sc_hd__decap_3
XFILLER_60_250 VGND VGND VPWR VPWR sky130_fd_sc_hd__fill_2
X_4842_ _4643_/Y _4841_/Y _4845_/A VGND VGND VPWR VPWR _4842_/X sky130_fd_sc_hd__a21o_2
XTAP_TAPCELL_ROW_31_621 VGND VPWR sky130_fd_sc_hd__tapvpwrvgnd_1
X_6512_ _6608_/A VGND VGND VPWR VPWR _6512_/Y sky130_fd_sc_hd__inv_2
X_3724_ _6828_/Q _3879_/A2 _3889_/A2 _6818_/Q _3723_/X VGND VGND VPWR VPWR _3724_/X
+ sky130_fd_sc_hd__a221o_2
X_6443_ _6570_/A VGND VGND VPWR VPWR _6443_/Y sky130_fd_sc_hd__inv_2
X_6374_ _6539_/A VGND VGND VPWR VPWR _6374_/Y sky130_fd_sc_hd__inv_2
X_3586_ _3591_/A _3591_/B _3591_/C _3586_/D VGND VGND VPWR VPWR _3586_/Y sky130_fd_sc_hd__nor4_2
XFILLER_102_403 VGND VGND VPWR VPWR sky130_fd_sc_hd__decap_3
XFILLER_114_230 VGND VGND VPWR VPWR sky130_fd_sc_hd__decap_3
XFILLER_88_604 VGND VGND VPWR VPWR sky130_fd_sc_hd__decap_3
X_5325_ _5325_/A0 _4964_/X _5350_/S VGND VGND VPWR VPWR _7168_/D sky130_fd_sc_hd__mux2_2
XFILLER_102_436 VGND VGND VPWR VPWR sky130_fd_sc_hd__fill_2
XFILLER_88_648 VGND VGND VPWR VPWR sky130_fd_sc_hd__decap_3
X_5256_ _5256_/A0 _4932_/X _5262_/S VGND VGND VPWR VPWR _7202_/D sky130_fd_sc_hd__mux2_2
XFILLER_57_18 VGND VGND VPWR VPWR sky130_fd_sc_hd__decap_3
XFILLER_87_158 VGND VGND VPWR VPWR sky130_fd_sc_hd__decap_3
XFILLER_87_169 VGND VGND VPWR VPWR sky130_fd_sc_hd__decap_3
X_4207_ _4207_/A _4642_/B VGND VGND VPWR VPWR _4208_/B sky130_fd_sc_hd__and2_2
XFILLER_28_203 VGND VGND VPWR VPWR sky130_fd_sc_hd__decap_3
XFILLER_68_361 VGND VGND VPWR VPWR sky130_fd_sc_hd__decap_3
XFILLER_68_383 VGND VGND VPWR VPWR sky130_fd_sc_hd__decap_3
XFILLER_113_24 VGND VGND VPWR VPWR sky130_fd_sc_hd__decap_3
X_4138_ _4134_/X _4137_/X _4425_/A VGND VGND VPWR VPWR _4642_/B sky130_fd_sc_hd__o21a_2
XTAP_TAPCELL_ROW_39_721 VGND VPWR sky130_fd_sc_hd__tapvpwrvgnd_1
XFILLER_113_57 VGND VGND VPWR VPWR sky130_fd_sc_hd__decap_3
X_4069_ _4744_/B _4069_/B VGND VGND VPWR VPWR _4610_/A sky130_fd_sc_hd__nor2_1
XFILLER_71_559 VGND VGND VPWR VPWR sky130_fd_sc_hd__fill_1
XFILLER_73_39 VGND VGND VPWR VPWR sky130_fd_sc_hd__decap_3
XTAP_TAPCELL_ROW_104_1502 VGND VPWR sky130_fd_sc_hd__tapvpwrvgnd_1
XFILLER_24_475 VGND VGND VPWR VPWR sky130_fd_sc_hd__fill_1
XFILLER_8_619 VGND VGND VPWR VPWR sky130_fd_sc_hd__decap_3
XFILLER_11_169 VGND VGND VPWR VPWR sky130_fd_sc_hd__decap_3
XFILLER_22_21 VGND VGND VPWR VPWR sky130_fd_sc_hd__decap_3
XFILLER_22_65 VGND VGND VPWR VPWR sky130_fd_sc_hd__decap_3
XTAP_TAPCELL_ROW_115_1631 VGND VPWR sky130_fd_sc_hd__tapvpwrvgnd_1
XFILLER_105_252 VGND VGND VPWR VPWR sky130_fd_sc_hd__decap_3
XFILLER_98_69 VGND VGND VPWR VPWR sky130_fd_sc_hd__decap_3
XFILLER_78_114 VGND VGND VPWR VPWR sky130_fd_sc_hd__decap_3
XFILLER_78_169 VGND VGND VPWR VPWR sky130_fd_sc_hd__fill_2
XFILLER_59_372 VGND VGND VPWR VPWR sky130_fd_sc_hd__decap_3
XFILLER_93_128 VGND VGND VPWR VPWR sky130_fd_sc_hd__decap_3
XFILLER_101_480 VGND VGND VPWR VPWR sky130_fd_sc_hd__decap_3
XFILLER_19_225 VGND VGND VPWR VPWR sky130_fd_sc_hd__decap_3
XFILLER_19_247 VGND VGND VPWR VPWR sky130_fd_sc_hd__decap_3
XFILLER_34_206 VGND VGND VPWR VPWR sky130_fd_sc_hd__decap_3
XFILLER_47_589 VGND VGND VPWR VPWR sky130_fd_sc_hd__decap_3
XFILLER_47_84 VGND VGND VPWR VPWR sky130_fd_sc_hd__decap_3
XFILLER_34_239 VGND VGND VPWR VPWR sky130_fd_sc_hd__decap_3
XFILLER_74_386 VGND VGND VPWR VPWR sky130_fd_sc_hd__decap_3
XFILLER_103_90 VGND VGND VPWR VPWR sky130_fd_sc_hd__decap_3
XFILLER_63_50 VGND VGND VPWR VPWR sky130_fd_sc_hd__decap_3
XTAP_TAPCELL_ROW_17_459 VGND VPWR sky130_fd_sc_hd__tapvpwrvgnd_1
XFILLER_30_456 VGND VGND VPWR VPWR sky130_fd_sc_hd__decap_3
XFILLER_42_283 VGND VGND VPWR VPWR sky130_fd_sc_hd__decap_3
XFILLER_8_23 VGND VGND VPWR VPWR sky130_fd_sc_hd__decap_3
XFILLER_8_56 VGND VGND VPWR VPWR sky130_fd_sc_hd__decap_3
XPHY_EDGE_ROW_7_Left_124 VGND VGND VPWR VPWR sky130_fd_sc_hd__decap_3
XFILLER_116_528 VGND VGND VPWR VPWR sky130_fd_sc_hd__decap_3
XFILLER_7_685 VGND VGND VPWR VPWR sky130_fd_sc_hd__decap_3
Xhold608 _6734_/Q VGND VGND VPWR VPWR _6734_/D sky130_fd_sc_hd__dlygate4sd3_1
XFILLER_6_195 VGND VGND VPWR VPWR sky130_fd_sc_hd__fill_1
Xhold619 _6850_/Q VGND VGND VPWR VPWR _6850_/D sky130_fd_sc_hd__dlygate4sd3_1
X_3440_ _7250_/Q _4601_/S _3434_/X _3439_/X VGND VGND VPWR VPWR _3440_/X sky130_fd_sc_hd__a211o_2
X_3371_ _3371_/A _5118_/D _5118_/A _3362_/A VGND VGND VPWR VPWR _3371_/Y sky130_fd_sc_hd__nor4bb_2
XFILLER_111_200 VGND VGND VPWR VPWR sky130_fd_sc_hd__decap_3
XFILLER_33_3 VGND VGND VPWR VPWR sky130_fd_sc_hd__decap_3
XFILLER_69_125 VGND VGND VPWR VPWR sky130_fd_sc_hd__decap_3
XFILLER_88_91 VGND VGND VPWR VPWR sky130_fd_sc_hd__decap_3
X_5110_ _3610_/A _3603_/Y _4292_/C VGND VGND VPWR VPWR _5110_/Y sky130_fd_sc_hd__a21oi_2
XTAP_TAPCELL_ROW_90_1336 VGND VPWR sky130_fd_sc_hd__tapvpwrvgnd_1
XFILLER_57_309 VGND VGND VPWR VPWR sky130_fd_sc_hd__decap_3
XFILLER_69_158 VGND VGND VPWR VPWR sky130_fd_sc_hd__decap_3
X_5041_ _5041_/A0 _5040_/X _5126_/S VGND VGND VPWR VPWR _7259_/D sky130_fd_sc_hd__mux2_2
XFILLER_69_169 VGND VGND VPWR VPWR sky130_fd_sc_hd__decap_3
XFILLER_78_670 VGND VGND VPWR VPWR sky130_fd_sc_hd__decap_3
XFILLER_65_320 VGND VGND VPWR VPWR sky130_fd_sc_hd__decap_3
XFILLER_38_589 VGND VGND VPWR VPWR sky130_fd_sc_hd__decap_3
XFILLER_93_662 VGND VGND VPWR VPWR sky130_fd_sc_hd__decap_3
XFILLER_93_673 VGND VGND VPWR VPWR sky130_fd_sc_hd__decap_3
XFILLER_25_239 VGND VGND VPWR VPWR sky130_fd_sc_hd__decap_3
XFILLER_80_312 VGND VGND VPWR VPWR sky130_fd_sc_hd__fill_2
XFILLER_80_323 VGND VGND VPWR VPWR sky130_fd_sc_hd__decap_3
X_6992_ _7338_/CLK _6992_/D _6272_/Y VGND VGND VPWR VPWR _6992_/Q sky130_fd_sc_hd__dfrtp_2
XFILLER_33_250 VGND VGND VPWR VPWR sky130_fd_sc_hd__decap_3
XFILLER_33_272 VGND VGND VPWR VPWR sky130_fd_sc_hd__decap_3
XFILLER_61_570 VGND VGND VPWR VPWR sky130_fd_sc_hd__fill_1
X_4825_ _7001_/Q _4825_/B VGND VGND VPWR VPWR _4826_/B sky130_fd_sc_hd__nor2_2
XFILLER_21_489 VGND VGND VPWR VPWR sky130_fd_sc_hd__decap_3
X_4687_ _7001_/Q _4687_/B VGND VGND VPWR VPWR _4834_/A sky130_fd_sc_hd__and2_2
X_3707_ _6937_/Q _3902_/A2 _3826_/B1 _6889_/Q VGND VGND VPWR VPWR _3707_/X sky130_fd_sc_hd__a22o_2
XFILLER_104_9 VGND VGND VPWR VPWR sky130_fd_sc_hd__decap_3
XFILLER_108_24 VGND VGND VPWR VPWR sky130_fd_sc_hd__decap_3
XFILLER_108_35 VGND VGND VPWR VPWR sky130_fd_sc_hd__decap_3
X_6426_ _6616_/A VGND VGND VPWR VPWR _6426_/Y sky130_fd_sc_hd__inv_2
X_3638_ _3635_/A _3618_/C _3547_/A VGND VGND VPWR VPWR _3638_/X sky130_fd_sc_hd__a21bo_2
XFILLER_108_68 VGND VGND VPWR VPWR sky130_fd_sc_hd__decap_3
XFILLER_115_561 VGND VGND VPWR VPWR sky130_fd_sc_hd__decap_3
XFILLER_68_17 VGND VGND VPWR VPWR sky130_fd_sc_hd__decap_3
X_6357_ _6388_/A VGND VGND VPWR VPWR _6357_/Y sky130_fd_sc_hd__inv_2
X_3569_ _7285_/Q _5136_/S _3567_/X _3568_/X VGND VGND VPWR VPWR _3569_/X sky130_fd_sc_hd__a211o_2
XFILLER_115_594 VGND VGND VPWR VPWR sky130_fd_sc_hd__decap_3
X_5308_ _5308_/A0 _4822_/X _5323_/S VGND VGND VPWR VPWR _7176_/D sky130_fd_sc_hd__mux2_2
XFILLER_102_244 VGND VGND VPWR VPWR sky130_fd_sc_hd__decap_3
XFILLER_76_607 VGND VGND VPWR VPWR sky130_fd_sc_hd__decap_3
XFILLER_88_445 VGND VGND VPWR VPWR sky130_fd_sc_hd__fill_1
XFILLER_88_467 VGND VGND VPWR VPWR sky130_fd_sc_hd__decap_3
X_6288_ _6288_/A VGND VGND VPWR VPWR _6288_/Y sky130_fd_sc_hd__inv_2
XFILLER_48_309 VGND VGND VPWR VPWR sky130_fd_sc_hd__decap_3
X_5239_ hold990/X _5238_/X _4766_/A VGND VGND VPWR VPWR _7211_/D sky130_fd_sc_hd__a21o_2
XTAP_TAPCELL_ROW_110_1572 VGND VPWR sky130_fd_sc_hd__tapvpwrvgnd_1
XFILLER_56_331 VGND VGND VPWR VPWR sky130_fd_sc_hd__decap_3
XFILLER_68_180 VGND VGND VPWR VPWR sky130_fd_sc_hd__decap_3
XFILLER_75_128 VGND VGND VPWR VPWR sky130_fd_sc_hd__decap_3
XFILLER_84_38 VGND VGND VPWR VPWR sky130_fd_sc_hd__decap_3
XFILLER_16_206 VGND VGND VPWR VPWR sky130_fd_sc_hd__decap_3
XFILLER_17_21 VGND VGND VPWR VPWR sky130_fd_sc_hd__decap_3
XFILLER_44_504 VGND VGND VPWR VPWR sky130_fd_sc_hd__decap_3
XFILLER_84_673 VGND VGND VPWR VPWR sky130_fd_sc_hd__decap_3
XFILLER_90_109 VGND VGND VPWR VPWR sky130_fd_sc_hd__decap_3
XFILLER_16_239 VGND VGND VPWR VPWR sky130_fd_sc_hd__fill_2
XFILLER_17_54 VGND VGND VPWR VPWR sky130_fd_sc_hd__fill_2
XFILLER_71_334 VGND VGND VPWR VPWR sky130_fd_sc_hd__fill_2
XFILLER_83_161 VGND VGND VPWR VPWR sky130_fd_sc_hd__fill_2
XFILLER_83_172 VGND VGND VPWR VPWR sky130_fd_sc_hd__decap_3
XFILLER_17_87 VGND VGND VPWR VPWR sky130_fd_sc_hd__fill_1
XFILLER_71_367 VGND VGND VPWR VPWR sky130_fd_sc_hd__decap_3
XTAP_TAPCELL_ROW_14_418 VGND VPWR sky130_fd_sc_hd__tapvpwrvgnd_1
XFILLER_12_434 VGND VGND VPWR VPWR sky130_fd_sc_hd__decap_3
XFILLER_24_283 VGND VGND VPWR VPWR sky130_fd_sc_hd__fill_2
XFILLER_52_592 VGND VGND VPWR VPWR sky130_fd_sc_hd__decap_3
XFILLER_8_405 VGND VGND VPWR VPWR sky130_fd_sc_hd__decap_3
XFILLER_8_449 VGND VGND VPWR VPWR sky130_fd_sc_hd__decap_3
XFILLER_3_143 VGND VGND VPWR VPWR sky130_fd_sc_hd__decap_3
XFILLER_4_666 VGND VGND VPWR VPWR sky130_fd_sc_hd__decap_3
XFILLER_98_209 VGND VGND VPWR VPWR sky130_fd_sc_hd__fill_2
XFILLER_79_423 VGND VGND VPWR VPWR sky130_fd_sc_hd__decap_3
XFILLER_67_607 VGND VGND VPWR VPWR sky130_fd_sc_hd__decap_3
XFILLER_58_50 VGND VGND VPWR VPWR sky130_fd_sc_hd__decap_3
XFILLER_58_72 VGND VGND VPWR VPWR sky130_fd_sc_hd__decap_3
XFILLER_66_106 VGND VGND VPWR VPWR sky130_fd_sc_hd__fill_2
XFILLER_66_117 VGND VGND VPWR VPWR sky130_fd_sc_hd__fill_1
XFILLER_58_94 VGND VGND VPWR VPWR sky130_fd_sc_hd__decap_3
XFILLER_75_662 VGND VGND VPWR VPWR sky130_fd_sc_hd__decap_3
XFILLER_75_673 VGND VGND VPWR VPWR sky130_fd_sc_hd__decap_3
XFILLER_47_375 VGND VGND VPWR VPWR sky130_fd_sc_hd__fill_2
XFILLER_47_386 VGND VGND VPWR VPWR sky130_fd_sc_hd__decap_3
XFILLER_74_161 VGND VGND VPWR VPWR sky130_fd_sc_hd__fill_2
XFILLER_90_621 VGND VGND VPWR VPWR sky130_fd_sc_hd__fill_2
XFILLER_74_82 VGND VGND VPWR VPWR sky130_fd_sc_hd__fill_2
XFILLER_90_676 VGND VGND VPWR VPWR sky130_fd_sc_hd__decap_3
XFILLER_15_261 VGND VGND VPWR VPWR sky130_fd_sc_hd__decap_3
XFILLER_22_209 VGND VGND VPWR VPWR sky130_fd_sc_hd__decap_3
XFILLER_30_253 VGND VGND VPWR VPWR sky130_fd_sc_hd__decap_3
XFILLER_90_70 VGND VGND VPWR VPWR sky130_fd_sc_hd__decap_3
X_4610_ _4610_/A _4762_/B VGND VGND VPWR VPWR _4611_/A sky130_fd_sc_hd__nand2_2
X_7260_ _7358_/CLK _7260_/D _6540_/Y VGND VGND VPWR VPWR _7260_/Q sky130_fd_sc_hd__dfrtp_2
XFILLER_104_509 VGND VGND VPWR VPWR sky130_fd_sc_hd__fill_2
X_7191_ _7386_/CLK _7191_/D _6471_/Y VGND VGND VPWR VPWR _7191_/Q sky130_fd_sc_hd__dfrtp_2
X_3423_ _3442_/A _3442_/B _4289_/B VGND VGND VPWR VPWR _3424_/S sky130_fd_sc_hd__and3_4
XFILLER_99_90 VGND VGND VPWR VPWR sky130_fd_sc_hd__decap_3
XFILLER_112_542 VGND VGND VPWR VPWR sky130_fd_sc_hd__decap_3
XFILLER_97_231 VGND VGND VPWR VPWR sky130_fd_sc_hd__fill_1
X_3354_ _3369_/A _5668_/A _3328_/B _5670_/A VGND VGND VPWR VPWR _3354_/X sky130_fd_sc_hd__a211o_2
XFILLER_58_618 VGND VGND VPWR VPWR sky130_fd_sc_hd__decap_3
XFILLER_85_426 VGND VGND VPWR VPWR sky130_fd_sc_hd__fill_2
XFILLER_97_264 VGND VGND VPWR VPWR sky130_fd_sc_hd__decap_3
Xhold1105 _7200_/Q VGND VGND VPWR VPWR _5260_/A0 sky130_fd_sc_hd__dlygate4sd3_1
XFILLER_66_640 VGND VGND VPWR VPWR sky130_fd_sc_hd__fill_1
Xhold1116 _7011_/Q VGND VGND VPWR VPWR _5634_/A sky130_fd_sc_hd__dlygate4sd3_1
Xhold1127 _7137_/Q VGND VGND VPWR VPWR _5392_/A0 sky130_fd_sc_hd__dlygate4sd3_1
Xhold1138 _7167_/Q VGND VGND VPWR VPWR _5327_/A0 sky130_fd_sc_hd__dlygate4sd3_1
Xhold1149 _7312_/Q VGND VGND VPWR VPWR _4534_/A0 sky130_fd_sc_hd__dlygate4sd3_1
X_5024_ _3833_/S _3832_/X _5015_/X _5023_/Y VGND VGND VPWR VPWR _5024_/X sky130_fd_sc_hd__a211o_2
XFILLER_65_150 VGND VGND VPWR VPWR sky130_fd_sc_hd__decap_3
XFILLER_66_651 VGND VGND VPWR VPWR sky130_fd_sc_hd__decap_3
XFILLER_26_515 VGND VGND VPWR VPWR sky130_fd_sc_hd__fill_2
XFILLER_38_386 VGND VGND VPWR VPWR sky130_fd_sc_hd__decap_3
XFILLER_65_172 VGND VGND VPWR VPWR sky130_fd_sc_hd__decap_3
XFILLER_66_684 VGND VGND VPWR VPWR sky130_fd_sc_hd__decap_3
XFILLER_81_632 VGND VGND VPWR VPWR sky130_fd_sc_hd__fill_2
XFILLER_93_470 VGND VGND VPWR VPWR sky130_fd_sc_hd__decap_3
XFILLER_26_559 VGND VGND VPWR VPWR sky130_fd_sc_hd__fill_1
XFILLER_53_356 VGND VGND VPWR VPWR sky130_fd_sc_hd__decap_3
X_6975_ _6975_/CLK _6975_/D VGND VGND VPWR VPWR _6975_/Q sky130_fd_sc_hd__dfxtp_2
XFILLER_41_529 VGND VGND VPWR VPWR sky130_fd_sc_hd__decap_3
XFILLER_80_153 VGND VGND VPWR VPWR sky130_fd_sc_hd__decap_3
XFILLER_81_676 VGND VGND VPWR VPWR sky130_fd_sc_hd__decap_3
XFILLER_110_47 VGND VGND VPWR VPWR sky130_fd_sc_hd__decap_3
XFILLER_21_220 VGND VGND VPWR VPWR sky130_fd_sc_hd__decap_3
XFILLER_80_186 VGND VGND VPWR VPWR sky130_fd_sc_hd__decap_3
XFILLER_21_231 VGND VGND VPWR VPWR sky130_fd_sc_hd__decap_3
XFILLER_70_18 VGND VGND VPWR VPWR sky130_fd_sc_hd__decap_3
XFILLER_70_29 VGND VGND VPWR VPWR sky130_fd_sc_hd__decap_3
XFILLER_5_419 VGND VGND VPWR VPWR sky130_fd_sc_hd__decap_3
X_4739_ _4762_/A _4762_/B _4765_/B _4610_/A VGND VGND VPWR VPWR _4739_/Y sky130_fd_sc_hd__a211oi_2
XFILLER_107_325 VGND VGND VPWR VPWR sky130_fd_sc_hd__decap_3
XFILLER_102_6 VGND VGND VPWR VPWR sky130_fd_sc_hd__decap_3
X_6409_ _6540_/A VGND VGND VPWR VPWR _6409_/Y sky130_fd_sc_hd__inv_2
XTAP_TAPCELL_ROW_112_1601 VGND VPWR sky130_fd_sc_hd__tapvpwrvgnd_1
X_7389_ _7392_/CLK _7389_/D _6669_/Y VGND VGND VPWR VPWR _7389_/Q sky130_fd_sc_hd__dfrtp_2
Xhold972 _7047_/Q VGND VGND VPWR VPWR hold972/X sky130_fd_sc_hd__dlygate4sd3_1
Xhold961 _7019_/Q VGND VGND VPWR VPWR _5617_/A sky130_fd_sc_hd__dlygate4sd3_1
Xhold950 _6703_/Q VGND VGND VPWR VPWR hold950/X sky130_fd_sc_hd__dlygate4sd3_1
XFILLER_0_113 VGND VGND VPWR VPWR sky130_fd_sc_hd__decap_3
XFILLER_0_135 VGND VGND VPWR VPWR sky130_fd_sc_hd__decap_3
XFILLER_1_647 VGND VGND VPWR VPWR sky130_fd_sc_hd__decap_3
XFILLER_88_242 VGND VGND VPWR VPWR sky130_fd_sc_hd__fill_1
Xhold994 _7017_/Q VGND VGND VPWR VPWR _5621_/A sky130_fd_sc_hd__dlygate4sd3_1
Xhold983 _7404_/Q VGND VGND VPWR VPWR hold983/X sky130_fd_sc_hd__dlygate4sd3_1
XFILLER_103_564 VGND VGND VPWR VPWR sky130_fd_sc_hd__decap_3
XFILLER_49_629 VGND VGND VPWR VPWR sky130_fd_sc_hd__decap_3
XFILLER_76_404 VGND VGND VPWR VPWR sky130_fd_sc_hd__decap_3
XFILLER_95_15 VGND VGND VPWR VPWR sky130_fd_sc_hd__decap_3
XFILLER_28_75 VGND VGND VPWR VPWR sky130_fd_sc_hd__decap_3
XFILLER_57_662 VGND VGND VPWR VPWR sky130_fd_sc_hd__decap_3
XFILLER_57_673 VGND VGND VPWR VPWR sky130_fd_sc_hd__decap_3
XTAP_TAPCELL_ROW_47_819 VGND VPWR sky130_fd_sc_hd__tapvpwrvgnd_1
XFILLER_28_97 VGND VGND VPWR VPWR sky130_fd_sc_hd__decap_3
XFILLER_29_386 VGND VGND VPWR VPWR sky130_fd_sc_hd__decap_3
XFILLER_44_312 VGND VGND VPWR VPWR sky130_fd_sc_hd__decap_3
XFILLER_56_172 VGND VGND VPWR VPWR sky130_fd_sc_hd__decap_3
XFILLER_72_610 VGND VGND VPWR VPWR sky130_fd_sc_hd__decap_3
XFILLER_91_429 VGND VGND VPWR VPWR sky130_fd_sc_hd__decap_3
XFILLER_44_345 VGND VGND VPWR VPWR sky130_fd_sc_hd__decap_3
XPHY_EDGE_ROW_88_Left_205 VGND VGND VPWR VPWR sky130_fd_sc_hd__decap_3
XFILLER_32_518 VGND VGND VPWR VPWR sky130_fd_sc_hd__decap_3
XFILLER_44_41 VGND VGND VPWR VPWR sky130_fd_sc_hd__decap_3
XFILLER_44_52 VGND VGND VPWR VPWR sky130_fd_sc_hd__fill_1
XFILLER_71_164 VGND VGND VPWR VPWR sky130_fd_sc_hd__decap_3
XFILLER_72_687 VGND VGND VPWR VPWR sky130_fd_sc_hd__decap_3
XTAP_TAPCELL_ROW_27_576 VGND VPWR sky130_fd_sc_hd__tapvpwrvgnd_1
XFILLER_44_85 VGND VGND VPWR VPWR sky130_fd_sc_hd__decap_3
XFILLER_12_253 VGND VGND VPWR VPWR sky130_fd_sc_hd__fill_1
XFILLER_12_286 VGND VGND VPWR VPWR sky130_fd_sc_hd__decap_3
XFILLER_40_573 VGND VGND VPWR VPWR sky130_fd_sc_hd__fill_2
XFILLER_67_9 VGND VGND VPWR VPWR sky130_fd_sc_hd__decap_3
XPHY_EDGE_ROW_97_Left_214 VGND VGND VPWR VPWR sky130_fd_sc_hd__decap_3
XFILLER_4_452 VGND VGND VPWR VPWR sky130_fd_sc_hd__decap_3
XFILLER_5_24 VGND VGND VPWR VPWR sky130_fd_sc_hd__decap_3
XFILLER_113_317 VGND VGND VPWR VPWR sky130_fd_sc_hd__fill_2
XFILLER_5_57 VGND VGND VPWR VPWR sky130_fd_sc_hd__decap_3
XTAP_TAPCELL_ROW_74_1139 VGND VPWR sky130_fd_sc_hd__tapvpwrvgnd_1
XFILLER_39_128 VGND VGND VPWR VPWR sky130_fd_sc_hd__decap_3
XFILLER_67_459 VGND VGND VPWR VPWR sky130_fd_sc_hd__fill_2
XFILLER_48_651 VGND VGND VPWR VPWR sky130_fd_sc_hd__decap_3
XFILLER_82_407 VGND VGND VPWR VPWR sky130_fd_sc_hd__decap_3
XFILLER_85_70 VGND VGND VPWR VPWR sky130_fd_sc_hd__decap_3
XFILLER_94_256 VGND VGND VPWR VPWR sky130_fd_sc_hd__decap_3
XFILLER_47_172 VGND VGND VPWR VPWR sky130_fd_sc_hd__decap_3
XFILLER_63_632 VGND VGND VPWR VPWR sky130_fd_sc_hd__decap_3
XFILLER_75_470 VGND VGND VPWR VPWR sky130_fd_sc_hd__decap_3
XFILLER_94_289 VGND VGND VPWR VPWR sky130_fd_sc_hd__decap_3
XFILLER_47_194 VGND VGND VPWR VPWR sky130_fd_sc_hd__decap_3
XFILLER_63_665 VGND VGND VPWR VPWR sky130_fd_sc_hd__decap_3
XFILLER_90_451 VGND VGND VPWR VPWR sky130_fd_sc_hd__decap_3
XFILLER_23_529 VGND VGND VPWR VPWR sky130_fd_sc_hd__decap_3
XFILLER_62_153 VGND VGND VPWR VPWR sky130_fd_sc_hd__decap_3
XFILLER_62_175 VGND VGND VPWR VPWR sky130_fd_sc_hd__decap_3
XFILLER_63_676 VGND VGND VPWR VPWR sky130_fd_sc_hd__decap_3
X_6760_ _6965_/CLK _6760_/D VGND VGND VPWR VPWR _6760_/Q sky130_fd_sc_hd__dfxtp_2
XTAP_TAPCELL_ROW_85_1268 VGND VPWR sky130_fd_sc_hd__tapvpwrvgnd_1
XFILLER_50_348 VGND VGND VPWR VPWR sky130_fd_sc_hd__decap_3
XFILLER_62_197 VGND VGND VPWR VPWR sky130_fd_sc_hd__decap_3
X_6691_ clkload4/A _6691_/D VGND VGND VPWR VPWR _6691_/Q sky130_fd_sc_hd__dfxtp_2
X_5642_ _5642_/A _5642_/B VGND VGND VPWR VPWR _5643_/A sky130_fd_sc_hd__or2_2
X_5573_ hold993/X _5015_/A _4975_/Y VGND VGND VPWR VPWR _7044_/D sky130_fd_sc_hd__o21a_2
XFILLER_116_100 VGND VGND VPWR VPWR sky130_fd_sc_hd__decap_3
X_7312_ _7356_/CLK _7312_/D _6592_/Y VGND VGND VPWR VPWR _7312_/Q sky130_fd_sc_hd__dfrtp_2
X_4524_ _7317_/Q _7285_/Q _4528_/B VGND VGND VPWR VPWR _7317_/D sky130_fd_sc_hd__mux2_2
XFILLER_116_144 VGND VGND VPWR VPWR sky130_fd_sc_hd__decap_3
X_7243_ _7374_/CLK _7243_/D _6523_/Y VGND VGND VPWR VPWR _7243_/Q sky130_fd_sc_hd__dfrtp_2
X_4455_ _4745_/A _4081_/X _4082_/X _4454_/X VGND VGND VPWR VPWR _4720_/B sky130_fd_sc_hd__o211a_2
X_7174_ _7338_/CLK _7174_/D _6454_/Y VGND VGND VPWR VPWR _7174_/Q sky130_fd_sc_hd__dfrtp_2
X_4386_ _7305_/Q _4488_/S _4437_/B1 _7369_/Q _4429_/C1 VGND VGND VPWR VPWR _4386_/X
+ sky130_fd_sc_hd__a221o_2
X_3406_ _3409_/D VGND VGND VPWR VPWR _3417_/C sky130_fd_sc_hd__inv_4
XFILLER_98_540 VGND VGND VPWR VPWR sky130_fd_sc_hd__decap_3
XFILLER_100_501 VGND VGND VPWR VPWR sky130_fd_sc_hd__decap_3
XFILLER_112_361 VGND VGND VPWR VPWR sky130_fd_sc_hd__decap_3
XFILLER_105_36 VGND VGND VPWR VPWR sky130_fd_sc_hd__decap_3
XFILLER_58_448 VGND VGND VPWR VPWR sky130_fd_sc_hd__decap_3
XFILLER_85_212 VGND VGND VPWR VPWR sky130_fd_sc_hd__decap_3
XFILLER_85_234 VGND VGND VPWR VPWR sky130_fd_sc_hd__decap_3
XFILLER_39_662 VGND VGND VPWR VPWR sky130_fd_sc_hd__decap_3
XFILLER_65_18 VGND VGND VPWR VPWR sky130_fd_sc_hd__decap_3
XFILLER_65_29 VGND VGND VPWR VPWR sky130_fd_sc_hd__decap_3
XFILLER_85_267 VGND VGND VPWR VPWR sky130_fd_sc_hd__decap_3
XFILLER_100_589 VGND VGND VPWR VPWR sky130_fd_sc_hd__decap_3
XFILLER_38_150 VGND VGND VPWR VPWR sky130_fd_sc_hd__decap_3
XFILLER_39_673 VGND VGND VPWR VPWR sky130_fd_sc_hd__decap_3
XFILLER_45_109 VGND VGND VPWR VPWR sky130_fd_sc_hd__decap_3
XFILLER_54_610 VGND VGND VPWR VPWR sky130_fd_sc_hd__decap_3
XFILLER_66_470 VGND VGND VPWR VPWR sky130_fd_sc_hd__decap_3
XFILLER_85_289 VGND VGND VPWR VPWR sky130_fd_sc_hd__fill_2
X_5007_ _5002_/Y _5003_/X _5004_/X _5005_/Y _5006_/X VGND VGND VPWR VPWR _5662_/A
+ sky130_fd_sc_hd__a221o_2
XFILLER_38_183 VGND VGND VPWR VPWR sky130_fd_sc_hd__decap_3
XFILLER_54_643 VGND VGND VPWR VPWR sky130_fd_sc_hd__fill_1
XFILLER_54_654 VGND VGND VPWR VPWR sky130_fd_sc_hd__decap_3
XFILLER_14_529 VGND VGND VPWR VPWR sky130_fd_sc_hd__decap_3
XFILLER_53_175 VGND VGND VPWR VPWR sky130_fd_sc_hd__decap_3
XFILLER_54_687 VGND VGND VPWR VPWR sky130_fd_sc_hd__decap_3
XFILLER_81_473 VGND VGND VPWR VPWR sky130_fd_sc_hd__decap_3
XFILLER_41_326 VGND VGND VPWR VPWR sky130_fd_sc_hd__decap_3
XFILLER_41_337 VGND VGND VPWR VPWR sky130_fd_sc_hd__decap_3
XFILLER_81_39 VGND VGND VPWR VPWR sky130_fd_sc_hd__fill_2
X_6958_ _6964_/CLK _6958_/D VGND VGND VPWR VPWR _6958_/Q sky130_fd_sc_hd__dfxtp_2
XTAP_TAPCELL_ROW_24_535 VGND VPWR sky130_fd_sc_hd__tapvpwrvgnd_1
XFILLER_14_44 VGND VGND VPWR VPWR sky130_fd_sc_hd__decap_3
X_6889_ _7005_/CLK _6889_/D VGND VGND VPWR VPWR _6889_/Q sky130_fd_sc_hd__dfxtp_2
XTAP_TAPCELL_ROW_52_877 VGND VPWR sky130_fd_sc_hd__tapvpwrvgnd_1
XFILLER_108_634 VGND VGND VPWR VPWR sky130_fd_sc_hd__decap_3
XFILLER_108_645 VGND VGND VPWR VPWR sky130_fd_sc_hd__decap_3
XFILLER_30_32 VGND VGND VPWR VPWR sky130_fd_sc_hd__fill_1
XFILLER_5_216 VGND VGND VPWR VPWR sky130_fd_sc_hd__decap_3
XFILLER_107_122 VGND VGND VPWR VPWR sky130_fd_sc_hd__fill_1
XFILLER_108_678 VGND VGND VPWR VPWR sky130_fd_sc_hd__decap_3
XFILLER_100_3 VGND VGND VPWR VPWR sky130_fd_sc_hd__decap_3
XFILLER_107_166 VGND VGND VPWR VPWR sky130_fd_sc_hd__fill_2
XFILLER_107_199 VGND VGND VPWR VPWR sky130_fd_sc_hd__decap_3
XFILLER_1_411 VGND VGND VPWR VPWR sky130_fd_sc_hd__decap_3
Xhold780 _6829_/Q VGND VGND VPWR VPWR _6829_/D sky130_fd_sc_hd__dlygate4sd3_1
Xhold791 _6810_/Q VGND VGND VPWR VPWR _6810_/D sky130_fd_sc_hd__dlygate4sd3_1
XFILLER_110_309 VGND VGND VPWR VPWR sky130_fd_sc_hd__decap_3
XFILLER_1_455 VGND VGND VPWR VPWR sky130_fd_sc_hd__decap_3
XFILLER_39_30 VGND VGND VPWR VPWR sky130_fd_sc_hd__decap_3
XFILLER_103_383 VGND VGND VPWR VPWR sky130_fd_sc_hd__decap_3
XFILLER_39_52 VGND VGND VPWR VPWR sky130_fd_sc_hd__decap_3
XFILLER_64_407 VGND VGND VPWR VPWR sky130_fd_sc_hd__decap_3
XFILLER_76_256 VGND VGND VPWR VPWR sky130_fd_sc_hd__fill_2
XFILLER_29_172 VGND VGND VPWR VPWR sky130_fd_sc_hd__decap_3
XFILLER_45_632 VGND VGND VPWR VPWR sky130_fd_sc_hd__decap_3
XFILLER_55_51 VGND VGND VPWR VPWR sky130_fd_sc_hd__decap_3
XFILLER_17_367 VGND VGND VPWR VPWR sky130_fd_sc_hd__decap_3
XFILLER_45_665 VGND VGND VPWR VPWR sky130_fd_sc_hd__decap_3
XFILLER_45_676 VGND VGND VPWR VPWR sky130_fd_sc_hd__decap_3
XFILLER_55_84 VGND VGND VPWR VPWR sky130_fd_sc_hd__decap_3
XFILLER_60_613 VGND VGND VPWR VPWR sky130_fd_sc_hd__decap_3
XFILLER_32_348 VGND VGND VPWR VPWR sky130_fd_sc_hd__decap_3
XFILLER_44_197 VGND VGND VPWR VPWR sky130_fd_sc_hd__fill_1
XFILLER_60_657 VGND VGND VPWR VPWR sky130_fd_sc_hd__decap_3
XFILLER_111_90 VGND VGND VPWR VPWR sky130_fd_sc_hd__decap_3
XFILLER_13_551 VGND VGND VPWR VPWR sky130_fd_sc_hd__decap_3
XFILLER_9_544 VGND VGND VPWR VPWR sky130_fd_sc_hd__decap_3
XFILLER_40_392 VGND VGND VPWR VPWR sky130_fd_sc_hd__fill_1
XFILLER_65_6 VGND VGND VPWR VPWR sky130_fd_sc_hd__decap_3
XFILLER_114_604 VGND VGND VPWR VPWR sky130_fd_sc_hd__decap_3
XFILLER_114_637 VGND VGND VPWR VPWR sky130_fd_sc_hd__decap_3
XFILLER_99_326 VGND VGND VPWR VPWR sky130_fd_sc_hd__decap_3
XFILLER_113_125 VGND VGND VPWR VPWR sky130_fd_sc_hd__decap_3
XFILLER_114_648 VGND VGND VPWR VPWR sky130_fd_sc_hd__decap_3
X_4240_ _4628_/A _4629_/B VGND VGND VPWR VPWR _4241_/B sky130_fd_sc_hd__and2_2
XFILLER_99_348 VGND VGND VPWR VPWR sky130_fd_sc_hd__decap_3
XFILLER_99_337 VGND VGND VPWR VPWR sky130_fd_sc_hd__decap_3
XFILLER_113_158 VGND VGND VPWR VPWR sky130_fd_sc_hd__decap_3
XFILLER_113_169 VGND VGND VPWR VPWR sky130_fd_sc_hd__decap_3
X_4171_ _4203_/A _4203_/B _4202_/A VGND VGND VPWR VPWR _4379_/B sky130_fd_sc_hd__a21oi_2
XFILLER_95_532 VGND VGND VPWR VPWR sky130_fd_sc_hd__decap_3
XFILLER_67_256 VGND VGND VPWR VPWR sky130_fd_sc_hd__fill_1
XFILLER_96_91 VGND VGND VPWR VPWR sky130_fd_sc_hd__decap_3
XFILLER_55_418 VGND VGND VPWR VPWR sky130_fd_sc_hd__decap_3
XFILLER_67_278 VGND VGND VPWR VPWR sky130_fd_sc_hd__fill_2
XFILLER_95_587 VGND VGND VPWR VPWR sky130_fd_sc_hd__decap_3
XFILLER_35_131 VGND VGND VPWR VPWR sky130_fd_sc_hd__decap_3
XFILLER_82_248 VGND VGND VPWR VPWR sky130_fd_sc_hd__decap_3
XFILLER_82_259 VGND VGND VPWR VPWR sky130_fd_sc_hd__decap_3
XFILLER_35_164 VGND VGND VPWR VPWR sky130_fd_sc_hd__decap_3
XFILLER_36_687 VGND VGND VPWR VPWR sky130_fd_sc_hd__decap_3
XFILLER_51_613 VGND VGND VPWR VPWR sky130_fd_sc_hd__decap_3
Xplace440 _5581_/S VGND VGND VPWR VPWR _5595_/B sky130_fd_sc_hd__buf_2
X_6812_ _6972_/CLK _6812_/D VGND VGND VPWR VPWR _6812_/Q sky130_fd_sc_hd__dfxtp_2
XFILLER_23_337 VGND VGND VPWR VPWR sky130_fd_sc_hd__fill_1
XFILLER_35_175 VGND VGND VPWR VPWR sky130_fd_sc_hd__decap_3
XFILLER_50_112 VGND VGND VPWR VPWR sky130_fd_sc_hd__decap_3
XFILLER_50_123 VGND VGND VPWR VPWR sky130_fd_sc_hd__decap_3
XFILLER_51_635 VGND VGND VPWR VPWR sky130_fd_sc_hd__decap_3
Xplace451 _7010_/Q VGND VGND VPWR VPWR _7010_/D sky130_fd_sc_hd__buf_2
XFILLER_23_359 VGND VGND VPWR VPWR sky130_fd_sc_hd__fill_1
XFILLER_51_668 VGND VGND VPWR VPWR sky130_fd_sc_hd__decap_3
XFILLER_51_679 VGND VGND VPWR VPWR sky130_fd_sc_hd__decap_3
X_6743_ _6959_/CLK _6743_/D VGND VGND VPWR VPWR _6743_/Q sky130_fd_sc_hd__dfxtp_2
X_6674_ _6674_/A VGND VGND VPWR VPWR _6674_/Y sky130_fd_sc_hd__inv_2
XTAP_TAPCELL_ROW_21_505 VGND VPWR sky130_fd_sc_hd__tapvpwrvgnd_1
X_3886_ _6920_/Q _3886_/A2 _3886_/B1 _6784_/Q VGND VGND VPWR VPWR _3886_/X sky130_fd_sc_hd__a22o_2
XTAP_TAPCELL_ROW_98_1426 VGND VPWR sky130_fd_sc_hd__tapvpwrvgnd_1
XFILLER_105_637 VGND VGND VPWR VPWR sky130_fd_sc_hd__decap_3
X_4507_ _4507_/A0 _7294_/Q _4517_/S VGND VGND VPWR VPWR _7326_/D sky130_fd_sc_hd__mux2_2
XFILLER_104_125 VGND VGND VPWR VPWR sky130_fd_sc_hd__decap_3
X_7226_ _7358_/CLK _7226_/D _6506_/Y VGND VGND VPWR VPWR _7226_/Q sky130_fd_sc_hd__dfrtp_2
X_4438_ _4434_/X _4437_/X _4425_/A VGND VGND VPWR VPWR _4650_/B sky130_fd_sc_hd__o21a_2
XFILLER_116_35 VGND VGND VPWR VPWR sky130_fd_sc_hd__decap_3
XFILLER_116_68 VGND VGND VPWR VPWR sky130_fd_sc_hd__decap_3
XFILLER_58_212 VGND VGND VPWR VPWR sky130_fd_sc_hd__decap_3
XFILLER_76_17 VGND VGND VPWR VPWR sky130_fd_sc_hd__fill_2
X_7157_ clkload7/A _7157_/D _6437_/Y VGND VGND VPWR VPWR _7157_/Q sky130_fd_sc_hd__dfrtp_2
X_4369_ _4369_/A _4369_/B VGND VGND VPWR VPWR _4369_/Y sky130_fd_sc_hd__nor2_2
XFILLER_98_392 VGND VGND VPWR VPWR sky130_fd_sc_hd__decap_3
XFILLER_100_353 VGND VGND VPWR VPWR sky130_fd_sc_hd__decap_3
XFILLER_112_180 VGND VGND VPWR VPWR sky130_fd_sc_hd__decap_3
XFILLER_58_256 VGND VGND VPWR VPWR sky130_fd_sc_hd__decap_3
X_7088_ clkload6/A _7088_/D _6368_/Y VGND VGND VPWR VPWR _7088_/Q sky130_fd_sc_hd__dfrtp_2
XFILLER_100_375 VGND VGND VPWR VPWR sky130_fd_sc_hd__decap_3
XFILLER_18_109 VGND VGND VPWR VPWR sky130_fd_sc_hd__decap_3
XFILLER_39_470 VGND VGND VPWR VPWR sky130_fd_sc_hd__decap_3
XFILLER_46_418 VGND VGND VPWR VPWR sky130_fd_sc_hd__fill_2
XFILLER_58_278 VGND VGND VPWR VPWR sky130_fd_sc_hd__decap_3
XFILLER_73_204 VGND VGND VPWR VPWR sky130_fd_sc_hd__decap_3
XFILLER_86_587 VGND VGND VPWR VPWR sky130_fd_sc_hd__fill_1
XTAP_TAPCELL_ROW_57_936 VGND VPWR sky130_fd_sc_hd__tapvpwrvgnd_1
XTAP_TAPCELL_ROW_29_605 VGND VPWR sky130_fd_sc_hd__tapvpwrvgnd_1
XFILLER_73_237 VGND VGND VPWR VPWR sky130_fd_sc_hd__decap_3
XFILLER_92_27 VGND VGND VPWR VPWR sky130_fd_sc_hd__fill_1
XTAP_TAPCELL_ROW_107_1533 VGND VPWR sky130_fd_sc_hd__tapvpwrvgnd_1
XFILLER_26_153 VGND VGND VPWR VPWR sky130_fd_sc_hd__decap_3
XFILLER_42_613 VGND VGND VPWR VPWR sky130_fd_sc_hd__decap_3
XFILLER_54_440 VGND VGND VPWR VPWR sky130_fd_sc_hd__fill_1
XFILLER_92_38 VGND VGND VPWR VPWR sky130_fd_sc_hd__decap_3
XTAP_TAPCELL_ROW_1_263 VGND VPWR sky130_fd_sc_hd__tapvpwrvgnd_1
XFILLER_14_315 VGND VGND VPWR VPWR sky130_fd_sc_hd__decap_3
XFILLER_26_186 VGND VGND VPWR VPWR sky130_fd_sc_hd__decap_3
XFILLER_26_197 VGND VGND VPWR VPWR sky130_fd_sc_hd__decap_3
XFILLER_81_292 VGND VGND VPWR VPWR sky130_fd_sc_hd__decap_3
XTAP_TAPCELL_ROW_37_693 VGND VPWR sky130_fd_sc_hd__tapvpwrvgnd_1
XFILLER_14_348 VGND VGND VPWR VPWR sky130_fd_sc_hd__decap_3
XFILLER_25_87 VGND VGND VPWR VPWR sky130_fd_sc_hd__decap_3
XFILLER_41_156 VGND VGND VPWR VPWR sky130_fd_sc_hd__fill_2
XFILLER_42_657 VGND VGND VPWR VPWR sky130_fd_sc_hd__decap_3
XFILLER_41_20 VGND VGND VPWR VPWR sky130_fd_sc_hd__decap_3
XFILLER_50_690 VGND VGND VPWR VPWR sky130_fd_sc_hd__fill_2
XFILLER_10_587 VGND VGND VPWR VPWR sky130_fd_sc_hd__fill_1
XFILLER_41_53 VGND VGND VPWR VPWR sky130_fd_sc_hd__decap_3
XFILLER_6_514 VGND VGND VPWR VPWR sky130_fd_sc_hd__fill_1
XFILLER_6_558 VGND VGND VPWR VPWR sky130_fd_sc_hd__decap_3
XFILLER_108_475 VGND VGND VPWR VPWR sky130_fd_sc_hd__fill_1
XFILLER_108_486 VGND VGND VPWR VPWR sky130_fd_sc_hd__decap_3
XTAP_TAPCELL_ROW_71_1109 VGND VPWR sky130_fd_sc_hd__tapvpwrvgnd_1
XFILLER_111_629 VGND VGND VPWR VPWR sky130_fd_sc_hd__decap_3
XFILLER_96_318 VGND VGND VPWR VPWR sky130_fd_sc_hd__decap_3
XTAP_TAPCELL_ROW_9_363 VGND VPWR sky130_fd_sc_hd__tapvpwrvgnd_1
XFILLER_104_681 VGND VGND VPWR VPWR sky130_fd_sc_hd__decap_3
XFILLER_110_139 VGND VGND VPWR VPWR sky130_fd_sc_hd__fill_1
XFILLER_2_14 VGND VGND VPWR VPWR sky130_fd_sc_hd__decap_3
XFILLER_77_532 VGND VGND VPWR VPWR sky130_fd_sc_hd__decap_3
XFILLER_2_47 VGND VGND VPWR VPWR sky130_fd_sc_hd__decap_3
XFILLER_49_234 VGND VGND VPWR VPWR sky130_fd_sc_hd__decap_3
XFILLER_49_267 VGND VGND VPWR VPWR sky130_fd_sc_hd__decap_3
XFILLER_66_72 VGND VGND VPWR VPWR sky130_fd_sc_hd__decap_3
XFILLER_18_632 VGND VGND VPWR VPWR sky130_fd_sc_hd__decap_3
XFILLER_66_83 VGND VGND VPWR VPWR sky130_fd_sc_hd__fill_1
XFILLER_17_153 VGND VGND VPWR VPWR sky130_fd_sc_hd__decap_3
XFILLER_92_579 VGND VGND VPWR VPWR sky130_fd_sc_hd__decap_3
XFILLER_17_175 VGND VGND VPWR VPWR sky130_fd_sc_hd__decap_3
XFILLER_32_123 VGND VGND VPWR VPWR sky130_fd_sc_hd__decap_3
XFILLER_60_421 VGND VGND VPWR VPWR sky130_fd_sc_hd__decap_3
XFILLER_72_292 VGND VGND VPWR VPWR sky130_fd_sc_hd__decap_3
XTAP_TAPCELL_ROW_82_1238 VGND VPWR sky130_fd_sc_hd__tapvpwrvgnd_1
XFILLER_33_679 VGND VGND VPWR VPWR sky130_fd_sc_hd__decap_3
XFILLER_82_71 VGND VGND VPWR VPWR sky130_fd_sc_hd__decap_3
XFILLER_20_307 VGND VGND VPWR VPWR sky130_fd_sc_hd__fill_1
XFILLER_32_167 VGND VGND VPWR VPWR sky130_fd_sc_hd__decap_3
X_3740_ _6710_/Q _5660_/B _3869_/B1 _6888_/Q _3739_/X VGND VGND VPWR VPWR _3740_/X
+ sky130_fd_sc_hd__a221o_2
XFILLER_9_330 VGND VGND VPWR VPWR sky130_fd_sc_hd__decap_3
X_3671_ hold995/X _3833_/S _3670_/X VGND VGND VPWR VPWR _7405_/D sky130_fd_sc_hd__o21a_2
X_6390_ _6616_/A VGND VGND VPWR VPWR _6390_/Y sky130_fd_sc_hd__inv_2
XTAP_TAPCELL_ROW_93_1367 VGND VPWR sky130_fd_sc_hd__tapvpwrvgnd_1
XFILLER_99_134 VGND VGND VPWR VPWR sky130_fd_sc_hd__decap_3
XFILLER_114_467 VGND VGND VPWR VPWR sky130_fd_sc_hd__fill_2
X_7011_ _7279_/CLK _7011_/D _6291_/Y VGND VGND VPWR VPWR _7011_/Q sky130_fd_sc_hd__dfrtp_2
X_5272_ _5272_/A0 _5061_/X _5274_/S VGND VGND VPWR VPWR _7194_/D sky130_fd_sc_hd__mux2_2
XFILLER_101_128 VGND VGND VPWR VPWR sky130_fd_sc_hd__fill_1
XFILLER_114_489 VGND VGND VPWR VPWR sky130_fd_sc_hd__decap_3
XFILLER_87_329 VGND VGND VPWR VPWR sky130_fd_sc_hd__decap_3
X_4223_ _4217_/X _4219_/X _4222_/X _4327_/A VGND VGND VPWR VPWR _4224_/C sky130_fd_sc_hd__o31a_2
XFILLER_110_640 VGND VGND VPWR VPWR sky130_fd_sc_hd__decap_3
XFILLER_110_651 VGND VGND VPWR VPWR sky130_fd_sc_hd__decap_3
XFILLER_95_340 VGND VGND VPWR VPWR sky130_fd_sc_hd__decap_3
X_4154_ _7047_/Q _4478_/S _4429_/B1 _7394_/Q _4153_/X VGND VGND VPWR VPWR _4154_/X
+ sky130_fd_sc_hd__a221o_2
XFILLER_110_684 VGND VGND VPWR VPWR sky130_fd_sc_hd__decap_3
XFILLER_55_204 VGND VGND VPWR VPWR sky130_fd_sc_hd__decap_3
XFILLER_68_587 VGND VGND VPWR VPWR sky130_fd_sc_hd__fill_1
XFILLER_83_502 VGND VGND VPWR VPWR sky130_fd_sc_hd__fill_2
X_4085_ _7238_/Q _4430_/A2 _4428_/B1 _7142_/Q _4084_/X VGND VGND VPWR VPWR _4085_/X
+ sky130_fd_sc_hd__a221o_2
XFILLER_55_248 VGND VGND VPWR VPWR sky130_fd_sc_hd__decap_3
XFILLER_102_15 VGND VGND VPWR VPWR sky130_fd_sc_hd__decap_3
XFILLER_83_579 VGND VGND VPWR VPWR sky130_fd_sc_hd__fill_2
XFILLER_102_48 VGND VGND VPWR VPWR sky130_fd_sc_hd__decap_3
XFILLER_63_281 VGND VGND VPWR VPWR sky130_fd_sc_hd__decap_3
XFILLER_51_432 VGND VGND VPWR VPWR sky130_fd_sc_hd__decap_3
Xplace281 _3661_/X VGND VGND VPWR VPWR _3892_/A2 sky130_fd_sc_hd__buf_2
Xplace270 _3869_/B1 VGND VGND VPWR VPWR _3826_/B1 sky130_fd_sc_hd__buf_2
XFILLER_11_329 VGND VGND VPWR VPWR sky130_fd_sc_hd__decap_3
XFILLER_23_178 VGND VGND VPWR VPWR sky130_fd_sc_hd__decap_3
XFILLER_51_487 VGND VGND VPWR VPWR sky130_fd_sc_hd__decap_3
Xplace292 _3891_/A2 VGND VGND VPWR VPWR _3913_/A2 sky130_fd_sc_hd__buf_2
X_6726_ _6976_/CLK _6726_/D VGND VGND VPWR VPWR _6726_/Q sky130_fd_sc_hd__dfxtp_2
X_4987_ _4987_/A _4987_/B VGND VGND VPWR VPWR _4987_/Y sky130_fd_sc_hd__xnor2_2
XTAP_TAPCELL_ROW_62_994 VGND VPWR sky130_fd_sc_hd__tapvpwrvgnd_1
XTAP_TAPCELL_ROW_34_663 VGND VPWR sky130_fd_sc_hd__tapvpwrvgnd_1
XFILLER_32_690 VGND VGND VPWR VPWR sky130_fd_sc_hd__fill_2
XTAP_TAPCELL_ROW_102_1474 VGND VPWR sky130_fd_sc_hd__tapvpwrvgnd_1
XFILLER_109_217 VGND VGND VPWR VPWR sky130_fd_sc_hd__decap_3
XFILLER_109_228 VGND VGND VPWR VPWR sky130_fd_sc_hd__decap_3
X_6657_ _6660_/A VGND VGND VPWR VPWR _6657_/Y sky130_fd_sc_hd__inv_2
X_3869_ _6772_/Q _3912_/A2 _3869_/B1 _6766_/Q VGND VGND VPWR VPWR _3869_/X sky130_fd_sc_hd__a22o_2
XFILLER_11_12 VGND VGND VPWR VPWR sky130_fd_sc_hd__decap_3
X_6588_ _6651_/A VGND VGND VPWR VPWR _6588_/Y sky130_fd_sc_hd__inv_2
XFILLER_11_45 VGND VGND VPWR VPWR sky130_fd_sc_hd__decap_3
XFILLER_105_423 VGND VGND VPWR VPWR sky130_fd_sc_hd__decap_3
XFILLER_78_318 VGND VGND VPWR VPWR sky130_fd_sc_hd__decap_3
XFILLER_87_27 VGND VGND VPWR VPWR sky130_fd_sc_hd__decap_3
XPHY_EDGE_ROW_52_Left_169 VGND VGND VPWR VPWR sky130_fd_sc_hd__decap_3
X_7209_ _7403_/CLK _7209_/D _6489_/Y VGND VGND VPWR VPWR _7209_/Q sky130_fd_sc_hd__dfrtp_2
XTAP_TAPCELL_ROW_6_322 VGND VPWR sky130_fd_sc_hd__tapvpwrvgnd_1
XFILLER_101_651 VGND VGND VPWR VPWR sky130_fd_sc_hd__decap_3
XFILLER_101_673 VGND VGND VPWR VPWR sky130_fd_sc_hd__decap_3
XFILLER_59_598 VGND VGND VPWR VPWR sky130_fd_sc_hd__decap_3
XFILLER_74_524 VGND VGND VPWR VPWR sky130_fd_sc_hd__decap_3
XFILLER_46_248 VGND VGND VPWR VPWR sky130_fd_sc_hd__decap_3
XFILLER_36_64 VGND VGND VPWR VPWR sky130_fd_sc_hd__decap_3
XFILLER_42_421 VGND VGND VPWR VPWR sky130_fd_sc_hd__fill_2
XTAP_TAPCELL_ROW_68_1071 VGND VPWR sky130_fd_sc_hd__tapvpwrvgnd_1
XPHY_EDGE_ROW_61_Left_178 VGND VGND VPWR VPWR sky130_fd_sc_hd__decap_3
XFILLER_15_646 VGND VGND VPWR VPWR sky130_fd_sc_hd__decap_3
XFILLER_54_292 VGND VGND VPWR VPWR sky130_fd_sc_hd__decap_3
XFILLER_52_41 VGND VGND VPWR VPWR sky130_fd_sc_hd__decap_3
XFILLER_52_85 VGND VGND VPWR VPWR sky130_fd_sc_hd__decap_3
XFILLER_10_362 VGND VGND VPWR VPWR sky130_fd_sc_hd__fill_2
XFILLER_108_250 VGND VGND VPWR VPWR sky130_fd_sc_hd__fill_2
XPHY_EDGE_ROW_70_Left_187 VGND VGND VPWR VPWR sky130_fd_sc_hd__decap_3
XFILLER_111_404 VGND VGND VPWR VPWR sky130_fd_sc_hd__fill_2
XFILLER_96_104 VGND VGND VPWR VPWR sky130_fd_sc_hd__decap_3
XFILLER_77_340 VGND VGND VPWR VPWR sky130_fd_sc_hd__decap_3
XFILLER_77_60 VGND VGND VPWR VPWR sky130_fd_sc_hd__decap_3
XFILLER_96_137 VGND VGND VPWR VPWR sky130_fd_sc_hd__decap_3
XFILLER_65_502 VGND VGND VPWR VPWR sky130_fd_sc_hd__fill_2
XFILLER_77_351 VGND VGND VPWR VPWR sky130_fd_sc_hd__decap_3
XFILLER_77_373 VGND VGND VPWR VPWR sky130_fd_sc_hd__decap_3
XFILLER_37_248 VGND VGND VPWR VPWR sky130_fd_sc_hd__decap_3
XFILLER_92_321 VGND VGND VPWR VPWR sky130_fd_sc_hd__decap_3
XFILLER_18_462 VGND VGND VPWR VPWR sky130_fd_sc_hd__decap_3
XFILLER_45_281 VGND VGND VPWR VPWR sky130_fd_sc_hd__decap_3
XFILLER_52_218 VGND VGND VPWR VPWR sky130_fd_sc_hd__decap_3
XFILLER_73_590 VGND VGND VPWR VPWR sky130_fd_sc_hd__decap_3
XFILLER_80_527 VGND VGND VPWR VPWR sky130_fd_sc_hd__decap_3
X_4910_ _5092_/C _4910_/B VGND VGND VPWR VPWR _4910_/Y sky130_fd_sc_hd__nand2_2
XFILLER_33_432 VGND VGND VPWR VPWR sky130_fd_sc_hd__decap_3
X_4841_ _4890_/B _4888_/B VGND VGND VPWR VPWR _4841_/Y sky130_fd_sc_hd__nand2b_2
XFILLER_60_273 VGND VGND VPWR VPWR sky130_fd_sc_hd__decap_3
XFILLER_20_115 VGND VGND VPWR VPWR sky130_fd_sc_hd__decap_3
XFILLER_20_137 VGND VGND VPWR VPWR sky130_fd_sc_hd__decap_3
X_4772_ _4772_/A0 _4771_/X _4772_/S VGND VGND VPWR VPWR _7275_/D sky130_fd_sc_hd__mux2_2
XTAP_TAPCELL_ROW_31_622 VGND VPWR sky130_fd_sc_hd__tapvpwrvgnd_1
XFILLER_20_159 VGND VGND VPWR VPWR sky130_fd_sc_hd__decap_3
X_6511_ _6548_/A VGND VGND VPWR VPWR _6511_/Y sky130_fd_sc_hd__inv_2
X_3723_ _6813_/Q _3878_/A2 _3878_/B1 _6823_/Q VGND VGND VPWR VPWR _3723_/X sky130_fd_sc_hd__a22o_2
X_6442_ _6535_/A VGND VGND VPWR VPWR _6442_/Y sky130_fd_sc_hd__inv_2
X_6373_ _6567_/A VGND VGND VPWR VPWR _6373_/Y sky130_fd_sc_hd__inv_2
X_3585_ _3591_/A _3591_/B _3591_/C _3586_/D VGND VGND VPWR VPWR _3599_/A sky130_fd_sc_hd__o31a_2
XFILLER_114_242 VGND VGND VPWR VPWR sky130_fd_sc_hd__decap_3
XFILLER_102_415 VGND VGND VPWR VPWR sky130_fd_sc_hd__decap_3
XFILLER_114_286 VGND VGND VPWR VPWR sky130_fd_sc_hd__fill_2
XFILLER_102_459 VGND VGND VPWR VPWR sky130_fd_sc_hd__decap_3
XFILLER_114_297 VGND VGND VPWR VPWR sky130_fd_sc_hd__decap_3
XFILLER_68_340 VGND VGND VPWR VPWR sky130_fd_sc_hd__decap_3
XFILLER_87_137 VGND VGND VPWR VPWR sky130_fd_sc_hd__decap_3
X_4206_ _4920_/A _4204_/Y _4205_/X VGND VGND VPWR VPWR _4206_/X sky130_fd_sc_hd__a21o_2
XFILLER_3_90 VGND VGND VPWR VPWR sky130_fd_sc_hd__decap_3
XFILLER_56_502 VGND VGND VPWR VPWR sky130_fd_sc_hd__decap_3
XFILLER_96_671 VGND VGND VPWR VPWR sky130_fd_sc_hd__decap_3
X_5186_ _5186_/A _5194_/B VGND VGND VPWR VPWR _7235_/D sky130_fd_sc_hd__and2_2
XFILLER_113_36 VGND VGND VPWR VPWR sky130_fd_sc_hd__decap_3
XFILLER_68_395 VGND VGND VPWR VPWR sky130_fd_sc_hd__decap_3
XFILLER_95_181 VGND VGND VPWR VPWR sky130_fd_sc_hd__decap_3
X_4137_ _7048_/Q _4501_/S _4196_/A2 _7395_/Q _4136_/X VGND VGND VPWR VPWR _4137_/X
+ sky130_fd_sc_hd__a221o_2
XTAP_TAPCELL_ROW_39_722 VGND VPWR sky130_fd_sc_hd__tapvpwrvgnd_1
XFILLER_113_69 VGND VGND VPWR VPWR sky130_fd_sc_hd__decap_3
XFILLER_28_259 VGND VGND VPWR VPWR sky130_fd_sc_hd__decap_3
XFILLER_43_207 VGND VGND VPWR VPWR sky130_fd_sc_hd__decap_3
XFILLER_71_505 VGND VGND VPWR VPWR sky130_fd_sc_hd__decap_3
X_4068_ _4068_/A _4082_/A VGND VGND VPWR VPWR _4069_/B sky130_fd_sc_hd__nor2_2
XTAP_TAPCELL_ROW_104_1503 VGND VPWR sky130_fd_sc_hd__tapvpwrvgnd_1
XFILLER_36_281 VGND VGND VPWR VPWR sky130_fd_sc_hd__decap_3
XFILLER_51_284 VGND VGND VPWR VPWR sky130_fd_sc_hd__decap_3
XFILLER_11_159 VGND VGND VPWR VPWR sky130_fd_sc_hd__fill_1
XFILLER_7_108 VGND VGND VPWR VPWR sky130_fd_sc_hd__decap_3
XFILLER_7_119 VGND VGND VPWR VPWR sky130_fd_sc_hd__decap_3
X_6709_ _7230_/CLK _6709_/D VGND VGND VPWR VPWR _6709_/Q sky130_fd_sc_hd__dfxtp_2
XFILLER_22_77 VGND VGND VPWR VPWR sky130_fd_sc_hd__decap_3
XFILLER_22_88 VGND VGND VPWR VPWR sky130_fd_sc_hd__decap_3
XFILLER_98_15 VGND VGND VPWR VPWR sky130_fd_sc_hd__decap_3
XTAP_TAPCELL_ROW_115_1632 VGND VPWR sky130_fd_sc_hd__tapvpwrvgnd_1
XFILLER_98_48 VGND VGND VPWR VPWR sky130_fd_sc_hd__decap_3
XFILLER_105_231 VGND VGND VPWR VPWR sky130_fd_sc_hd__decap_3
XFILLER_3_369 VGND VGND VPWR VPWR sky130_fd_sc_hd__decap_3
XFILLER_79_605 VGND VGND VPWR VPWR sky130_fd_sc_hd__decap_3
XFILLER_78_126 VGND VGND VPWR VPWR sky130_fd_sc_hd__decap_3
XFILLER_78_159 VGND VGND VPWR VPWR sky130_fd_sc_hd__decap_3
Xoutput490 _5117_/B VGND VGND VPWR VPWR alu_result_out[7] sky130_fd_sc_hd__clkdlybuf4s25_1
XFILLER_47_30 VGND VGND VPWR VPWR sky130_fd_sc_hd__decap_3
XFILLER_47_502 VGND VGND VPWR VPWR sky130_fd_sc_hd__fill_2
XFILLER_87_682 VGND VGND VPWR VPWR sky130_fd_sc_hd__decap_3
XFILLER_101_492 VGND VGND VPWR VPWR sky130_fd_sc_hd__decap_3
XFILLER_47_63 VGND VGND VPWR VPWR sky130_fd_sc_hd__decap_3
XFILLER_59_384 VGND VGND VPWR VPWR sky130_fd_sc_hd__decap_3
XFILLER_19_259 VGND VGND VPWR VPWR sky130_fd_sc_hd__decap_3
XFILLER_47_96 VGND VGND VPWR VPWR sky130_fd_sc_hd__decap_3
XFILLER_74_343 VGND VGND VPWR VPWR sky130_fd_sc_hd__fill_1
XFILLER_74_365 VGND VGND VPWR VPWR sky130_fd_sc_hd__decap_3
XFILLER_34_218 VGND VGND VPWR VPWR sky130_fd_sc_hd__decap_3
XFILLER_27_281 VGND VGND VPWR VPWR sky130_fd_sc_hd__decap_3
XFILLER_30_402 VGND VGND VPWR VPWR sky130_fd_sc_hd__decap_3
XFILLER_42_251 VGND VGND VPWR VPWR sky130_fd_sc_hd__fill_1
XFILLER_42_262 VGND VGND VPWR VPWR sky130_fd_sc_hd__decap_3
XFILLER_63_84 VGND VGND VPWR VPWR sky130_fd_sc_hd__decap_3
XFILLER_97_9 VGND VGND VPWR VPWR sky130_fd_sc_hd__decap_3
XFILLER_30_468 VGND VGND VPWR VPWR sky130_fd_sc_hd__decap_3
XFILLER_8_35 VGND VGND VPWR VPWR sky130_fd_sc_hd__decap_3
XFILLER_11_671 VGND VGND VPWR VPWR sky130_fd_sc_hd__fill_1
XFILLER_8_68 VGND VGND VPWR VPWR sky130_fd_sc_hd__decap_3
XFILLER_6_130 VGND VGND VPWR VPWR sky130_fd_sc_hd__decap_3
XFILLER_6_141 VGND VGND VPWR VPWR sky130_fd_sc_hd__decap_3
Xhold609 _6814_/Q VGND VGND VPWR VPWR _6814_/D sky130_fd_sc_hd__dlygate4sd3_1
Xwire562 _4273_/Y VGND VGND VPWR VPWR wire562/X sky130_fd_sc_hd__clkdlybuf4s25_1
X_3370_ _6982_/Q _5670_/A VGND VGND VPWR VPWR _3370_/Y sky130_fd_sc_hd__nor2_2
XFILLER_69_104 VGND VGND VPWR VPWR sky130_fd_sc_hd__decap_3
XFILLER_88_70 VGND VGND VPWR VPWR sky130_fd_sc_hd__decap_3
XFILLER_97_402 VGND VGND VPWR VPWR sky130_fd_sc_hd__fill_2
XFILLER_97_435 VGND VGND VPWR VPWR sky130_fd_sc_hd__decap_3
XTAP_TAPCELL_ROW_90_1337 VGND VPWR sky130_fd_sc_hd__tapvpwrvgnd_1
XTAP_TAPCELL_ROW_90_1326 VGND VPWR sky130_fd_sc_hd__tapvpwrvgnd_1
XFILLER_2_380 VGND VGND VPWR VPWR sky130_fd_sc_hd__decap_3
XFILLER_97_457 VGND VGND VPWR VPWR sky130_fd_sc_hd__decap_3
X_5040_ _6989_/D _5039_/X _5156_/S VGND VGND VPWR VPWR _5040_/X sky130_fd_sc_hd__mux2_2
XFILLER_26_3 VGND VGND VPWR VPWR sky130_fd_sc_hd__decap_3
XFILLER_78_682 VGND VGND VPWR VPWR sky130_fd_sc_hd__fill_2
XFILLER_84_107 VGND VGND VPWR VPWR sky130_fd_sc_hd__decap_3
XFILLER_97_479 VGND VGND VPWR VPWR sky130_fd_sc_hd__decap_3
XPHY_EDGE_ROW_108_Left_225 VGND VGND VPWR VPWR sky130_fd_sc_hd__decap_3
XFILLER_65_332 VGND VGND VPWR VPWR sky130_fd_sc_hd__decap_3
XFILLER_93_641 VGND VGND VPWR VPWR sky130_fd_sc_hd__decap_3
XFILLER_53_505 VGND VGND VPWR VPWR sky130_fd_sc_hd__fill_1
XFILLER_65_343 VGND VGND VPWR VPWR sky130_fd_sc_hd__decap_3
X_6991_ _7338_/CLK _6991_/D _6271_/Y VGND VGND VPWR VPWR _6991_/Q sky130_fd_sc_hd__dfrtp_2
XFILLER_80_302 VGND VGND VPWR VPWR sky130_fd_sc_hd__decap_3
XFILLER_80_368 VGND VGND VPWR VPWR sky130_fd_sc_hd__fill_1
XFILLER_92_195 VGND VGND VPWR VPWR sky130_fd_sc_hd__fill_1
XFILLER_80_379 VGND VGND VPWR VPWR sky130_fd_sc_hd__fill_1
XFILLER_21_446 VGND VGND VPWR VPWR sky130_fd_sc_hd__fill_2
XTAP_TAPCELL_ROW_44_780 VGND VPWR sky130_fd_sc_hd__tapvpwrvgnd_1
XFILLER_21_457 VGND VGND VPWR VPWR sky130_fd_sc_hd__fill_2
XFILLER_21_468 VGND VGND VPWR VPWR sky130_fd_sc_hd__decap_3
X_4755_ _7005_/Q _4775_/A VGND VGND VPWR VPWR _7005_/D sky130_fd_sc_hd__xor2_2
X_4686_ _6999_/Q _7000_/Q _4858_/B VGND VGND VPWR VPWR _4687_/B sky130_fd_sc_hd__and3_2
X_6425_ _6584_/A VGND VGND VPWR VPWR _6425_/Y sky130_fd_sc_hd__inv_2
X_3637_ _3636_/Y _5146_/B1 _3505_/X _3618_/X VGND VGND VPWR VPWR _3637_/X sky130_fd_sc_hd__a22o_2
XFILLER_108_47 VGND VGND VPWR VPWR sky130_fd_sc_hd__decap_3
XFILLER_115_551 VGND VGND VPWR VPWR sky130_fd_sc_hd__decap_3
X_6356_ _6388_/A VGND VGND VPWR VPWR _6356_/Y sky130_fd_sc_hd__inv_2
X_3568_ _7093_/Q _4321_/A2 _3407_/X _7125_/Q VGND VGND VPWR VPWR _3568_/X sky130_fd_sc_hd__a22o_2
XFILLER_115_573 VGND VGND VPWR VPWR sky130_fd_sc_hd__decap_3
XFILLER_68_29 VGND VGND VPWR VPWR sky130_fd_sc_hd__decap_3
XFILLER_88_424 VGND VGND VPWR VPWR sky130_fd_sc_hd__decap_3
X_6287_ _6288_/A VGND VGND VPWR VPWR _6287_/Y sky130_fd_sc_hd__inv_2
X_3499_ _4537_/C _4289_/B _3497_/X _5152_/B VGND VGND VPWR VPWR _3541_/B sky130_fd_sc_hd__a31oi_4
XFILLER_29_513 VGND VGND VPWR VPWR sky130_fd_sc_hd__decap_3
XFILLER_69_660 VGND VGND VPWR VPWR sky130_fd_sc_hd__decap_3
XFILLER_69_671 VGND VGND VPWR VPWR sky130_fd_sc_hd__fill_1
XFILLER_76_619 VGND VGND VPWR VPWR sky130_fd_sc_hd__decap_3
X_5238_ _5362_/C _5238_/B _4348_/B1 VGND VGND VPWR VPWR _5238_/X sky130_fd_sc_hd__or3b_2
XTAP_TAPCELL_ROW_110_1573 VGND VPWR sky130_fd_sc_hd__tapvpwrvgnd_1
XFILLER_56_321 VGND VGND VPWR VPWR sky130_fd_sc_hd__decap_3
XFILLER_69_682 VGND VGND VPWR VPWR sky130_fd_sc_hd__decap_3
XFILLER_84_630 VGND VGND VPWR VPWR sky130_fd_sc_hd__decap_3
X_5169_ _5169_/A _5182_/B VGND VGND VPWR VPWR _7243_/D sky130_fd_sc_hd__and2_2
XFILLER_56_343 VGND VGND VPWR VPWR sky130_fd_sc_hd__decap_3
XFILLER_56_365 VGND VGND VPWR VPWR sky130_fd_sc_hd__decap_3
XFILLER_68_192 VGND VGND VPWR VPWR sky130_fd_sc_hd__decap_3
XFILLER_83_140 VGND VGND VPWR VPWR sky130_fd_sc_hd__decap_3
XFILLER_17_33 VGND VGND VPWR VPWR sky130_fd_sc_hd__decap_3
XFILLER_71_324 VGND VGND VPWR VPWR sky130_fd_sc_hd__fill_2
XFILLER_84_685 VGND VGND VPWR VPWR sky130_fd_sc_hd__decap_3
XTAP_TAPCELL_ROW_65_1030 VGND VPWR sky130_fd_sc_hd__tapvpwrvgnd_1
XFILLER_24_240 VGND VGND VPWR VPWR sky130_fd_sc_hd__decap_3
XFILLER_24_262 VGND VGND VPWR VPWR sky130_fd_sc_hd__decap_3
XFILLER_52_560 VGND VGND VPWR VPWR sky130_fd_sc_hd__fill_2
XFILLER_71_379 VGND VGND VPWR VPWR sky130_fd_sc_hd__decap_3
XTAP_TAPCELL_ROW_14_419 VGND VPWR sky130_fd_sc_hd__tapvpwrvgnd_1
XFILLER_33_54 VGND VGND VPWR VPWR sky130_fd_sc_hd__fill_2
XFILLER_8_417 VGND VGND VPWR VPWR sky130_fd_sc_hd__decap_3
XFILLER_33_87 VGND VGND VPWR VPWR sky130_fd_sc_hd__decap_3
XFILLER_3_111 VGND VGND VPWR VPWR sky130_fd_sc_hd__fill_1
XFILLER_106_551 VGND VGND VPWR VPWR sky130_fd_sc_hd__decap_3
XFILLER_3_122 VGND VGND VPWR VPWR sky130_fd_sc_hd__decap_3
XFILLER_4_645 VGND VGND VPWR VPWR sky130_fd_sc_hd__decap_3
XFILLER_106_584 VGND VGND VPWR VPWR sky130_fd_sc_hd__fill_1
XFILLER_3_177 VGND VGND VPWR VPWR sky130_fd_sc_hd__fill_2
XFILLER_4_678 VGND VGND VPWR VPWR sky130_fd_sc_hd__decap_3
XFILLER_79_402 VGND VGND VPWR VPWR sky130_fd_sc_hd__decap_3
XFILLER_106_595 VGND VGND VPWR VPWR sky130_fd_sc_hd__fill_2
XFILLER_79_468 VGND VGND VPWR VPWR sky130_fd_sc_hd__decap_3
XFILLER_12_9 VGND VGND VPWR VPWR sky130_fd_sc_hd__decap_3
XFILLER_47_321 VGND VGND VPWR VPWR sky130_fd_sc_hd__decap_3
XFILLER_59_181 VGND VGND VPWR VPWR sky130_fd_sc_hd__decap_3
XFILLER_66_129 VGND VGND VPWR VPWR sky130_fd_sc_hd__decap_3
XFILLER_35_505 VGND VGND VPWR VPWR sky130_fd_sc_hd__fill_1
XFILLER_74_50 VGND VGND VPWR VPWR sky130_fd_sc_hd__decap_3
XFILLER_75_685 VGND VGND VPWR VPWR sky130_fd_sc_hd__decap_3
XFILLER_15_240 VGND VGND VPWR VPWR sky130_fd_sc_hd__fill_1
XFILLER_62_368 VGND VGND VPWR VPWR sky130_fd_sc_hd__decap_3
XFILLER_90_688 VGND VGND VPWR VPWR sky130_fd_sc_hd__decap_3
XFILLER_15_273 VGND VGND VPWR VPWR sky130_fd_sc_hd__decap_3
XFILLER_15_284 VGND VGND VPWR VPWR sky130_fd_sc_hd__decap_3
XFILLER_30_221 VGND VGND VPWR VPWR sky130_fd_sc_hd__decap_3
XFILLER_95_6 VGND VGND VPWR VPWR sky130_fd_sc_hd__decap_3
XFILLER_90_82 VGND VGND VPWR VPWR sky130_fd_sc_hd__fill_2
XFILLER_30_287 VGND VGND VPWR VPWR sky130_fd_sc_hd__decap_3
XFILLER_116_304 VGND VGND VPWR VPWR sky130_fd_sc_hd__decap_3
Xclkbuf_leaf_10_clk clkbuf_leaf_4_clk/A VGND VGND VPWR VPWR _7397_/CLK sky130_fd_sc_hd__clkbuf_16
X_4540_ _4540_/A _4561_/B VGND VGND VPWR VPWR _7310_/D sky130_fd_sc_hd__and2_2
XFILLER_116_337 VGND VGND VPWR VPWR sky130_fd_sc_hd__decap_3
X_4471_ _4471_/A0 _4470_/X _4471_/S VGND VGND VPWR VPWR _7343_/D sky130_fd_sc_hd__mux2_2
XFILLER_116_359 VGND VGND VPWR VPWR sky130_fd_sc_hd__decap_3
X_7190_ clkload5/A _7190_/D _6470_/Y VGND VGND VPWR VPWR _7190_/Q sky130_fd_sc_hd__dfrtp_2
XFILLER_112_521 VGND VGND VPWR VPWR sky130_fd_sc_hd__decap_3
XFILLER_97_243 VGND VGND VPWR VPWR sky130_fd_sc_hd__decap_3
X_3353_ _3353_/A _3362_/A VGND VGND VPWR VPWR _5668_/A sky130_fd_sc_hd__xor2_2
XFILLER_112_554 VGND VGND VPWR VPWR sky130_fd_sc_hd__fill_2
XFILLER_85_405 VGND VGND VPWR VPWR sky130_fd_sc_hd__decap_3
XFILLER_97_276 VGND VGND VPWR VPWR sky130_fd_sc_hd__decap_3
Xhold1106 _7243_/Q VGND VGND VPWR VPWR _5169_/A sky130_fd_sc_hd__dlygate4sd3_1
XFILLER_112_598 VGND VGND VPWR VPWR sky130_fd_sc_hd__decap_3
XFILLER_57_118 VGND VGND VPWR VPWR sky130_fd_sc_hd__decap_3
XFILLER_85_449 VGND VGND VPWR VPWR sky130_fd_sc_hd__decap_3
XFILLER_97_287 VGND VGND VPWR VPWR sky130_fd_sc_hd__decap_3
Xhold1117 _7251_/Q VGND VGND VPWR VPWR _5136_/A0 sky130_fd_sc_hd__dlygate4sd3_1
Xhold1128 _7255_/Q VGND VGND VPWR VPWR _5108_/A0 sky130_fd_sc_hd__dlygate4sd3_1
Xhold1139 _7314_/Q VGND VGND VPWR VPWR _4530_/A0 sky130_fd_sc_hd__dlygate4sd3_1
X_5023_ _5661_/A VGND VGND VPWR VPWR _5023_/Y sky130_fd_sc_hd__inv_2
XFILLER_38_343 VGND VGND VPWR VPWR sky130_fd_sc_hd__decap_3
XFILLER_66_663 VGND VGND VPWR VPWR sky130_fd_sc_hd__decap_3
Xsingle_cycle_cpu_580 VGND VGND VPWR VPWR instruction_out[1] single_cycle_cpu_580/LO
+ sky130_fd_sc_hd__conb_1
XFILLER_38_365 VGND VGND VPWR VPWR sky130_fd_sc_hd__decap_3
XFILLER_38_398 VGND VGND VPWR VPWR sky130_fd_sc_hd__fill_2
XFILLER_65_162 VGND VGND VPWR VPWR sky130_fd_sc_hd__decap_3
XFILLER_81_611 VGND VGND VPWR VPWR sky130_fd_sc_hd__fill_1
XFILLER_93_482 VGND VGND VPWR VPWR sky130_fd_sc_hd__decap_3
XFILLER_0_80 VGND VGND VPWR VPWR sky130_fd_sc_hd__decap_3
XFILLER_19_590 VGND VGND VPWR VPWR sky130_fd_sc_hd__decap_3
XFILLER_53_346 VGND VGND VPWR VPWR sky130_fd_sc_hd__fill_2
XFILLER_65_184 VGND VGND VPWR VPWR sky130_fd_sc_hd__decap_3
XFILLER_81_655 VGND VGND VPWR VPWR sky130_fd_sc_hd__decap_3
X_6974_ _6976_/CLK _6974_/D VGND VGND VPWR VPWR _6974_/Q sky130_fd_sc_hd__dfxtp_2
XFILLER_110_15 VGND VGND VPWR VPWR sky130_fd_sc_hd__decap_3
XFILLER_41_508 VGND VGND VPWR VPWR sky130_fd_sc_hd__fill_1
XFILLER_53_368 VGND VGND VPWR VPWR sky130_fd_sc_hd__decap_3
XFILLER_80_165 VGND VGND VPWR VPWR sky130_fd_sc_hd__decap_3
XFILLER_81_688 VGND VGND VPWR VPWR sky130_fd_sc_hd__decap_3
XFILLER_110_59 VGND VGND VPWR VPWR sky130_fd_sc_hd__decap_3
XFILLER_61_390 VGND VGND VPWR VPWR sky130_fd_sc_hd__fill_2
XFILLER_21_243 VGND VGND VPWR VPWR sky130_fd_sc_hd__decap_3
X_4807_ _4807_/A0 _4806_/X _4879_/S VGND VGND VPWR VPWR _7273_/D sky130_fd_sc_hd__mux2_2
XPHY_EDGE_ROW_3_Right_3 VGND VGND VPWR VPWR sky130_fd_sc_hd__decap_3
XFILLER_21_287 VGND VGND VPWR VPWR sky130_fd_sc_hd__decap_3
XFILLER_107_304 VGND VGND VPWR VPWR sky130_fd_sc_hd__decap_3
X_4738_ _4738_/A _4738_/B VGND VGND VPWR VPWR _7006_/D sky130_fd_sc_hd__nor2_2
X_4669_ _6995_/Q _4672_/B VGND VGND VPWR VPWR _4928_/B sky130_fd_sc_hd__and2_2
XFILLER_107_348 VGND VGND VPWR VPWR sky130_fd_sc_hd__decap_3
Xhold940 _7028_/Q VGND VGND VPWR VPWR hold940/X sky130_fd_sc_hd__dlygate4sd3_1
X_6408_ _6570_/A VGND VGND VPWR VPWR _6408_/Y sky130_fd_sc_hd__inv_2
XFILLER_1_615 VGND VGND VPWR VPWR sky130_fd_sc_hd__fill_1
XFILLER_1_626 VGND VGND VPWR VPWR sky130_fd_sc_hd__decap_3
X_7388_ _7392_/CLK _7388_/D _6668_/Y VGND VGND VPWR VPWR _7388_/Q sky130_fd_sc_hd__dfrtp_2
Xhold973 _7375_/Q VGND VGND VPWR VPWR hold973/X sky130_fd_sc_hd__dlygate4sd3_1
Xhold962 _7052_/Q VGND VGND VPWR VPWR hold962/X sky130_fd_sc_hd__dlygate4sd3_1
Xhold951 _7050_/Q VGND VGND VPWR VPWR hold951/X sky130_fd_sc_hd__dlygate4sd3_1
XFILLER_1_659 VGND VGND VPWR VPWR sky130_fd_sc_hd__decap_3
XFILLER_88_221 VGND VGND VPWR VPWR sky130_fd_sc_hd__decap_3
Xhold995 _7405_/Q VGND VGND VPWR VPWR hold995/X sky130_fd_sc_hd__dlygate4sd3_1
Xhold984 _7390_/Q VGND VGND VPWR VPWR hold984/X sky130_fd_sc_hd__dlygate4sd3_1
X_6339_ _6347_/A VGND VGND VPWR VPWR _6339_/Y sky130_fd_sc_hd__inv_2
XFILLER_0_147 VGND VGND VPWR VPWR sky130_fd_sc_hd__fill_2
XFILLER_0_169 VGND VGND VPWR VPWR sky130_fd_sc_hd__decap_3
XFILLER_49_608 VGND VGND VPWR VPWR sky130_fd_sc_hd__decap_3
XFILLER_88_265 VGND VGND VPWR VPWR sky130_fd_sc_hd__decap_3
XFILLER_95_38 VGND VGND VPWR VPWR sky130_fd_sc_hd__decap_3
XFILLER_76_438 VGND VGND VPWR VPWR sky130_fd_sc_hd__decap_3
XFILLER_28_43 VGND VGND VPWR VPWR sky130_fd_sc_hd__fill_2
XFILLER_28_54 VGND VGND VPWR VPWR sky130_fd_sc_hd__decap_3
XFILLER_57_641 VGND VGND VPWR VPWR sky130_fd_sc_hd__decap_3
XFILLER_17_505 VGND VGND VPWR VPWR sky130_fd_sc_hd__decap_3
XFILLER_44_302 VGND VGND VPWR VPWR sky130_fd_sc_hd__decap_3
XFILLER_57_685 VGND VGND VPWR VPWR sky130_fd_sc_hd__decap_3
XFILLER_72_600 VGND VGND VPWR VPWR sky130_fd_sc_hd__decap_3
XFILLER_84_460 VGND VGND VPWR VPWR sky130_fd_sc_hd__decap_3
XFILLER_44_324 VGND VGND VPWR VPWR sky130_fd_sc_hd__decap_3
XFILLER_44_357 VGND VGND VPWR VPWR sky130_fd_sc_hd__decap_3
XFILLER_56_195 VGND VGND VPWR VPWR sky130_fd_sc_hd__fill_1
XFILLER_71_132 VGND VGND VPWR VPWR sky130_fd_sc_hd__decap_3
XFILLER_71_176 VGND VGND VPWR VPWR sky130_fd_sc_hd__fill_2
XTAP_TAPCELL_ROW_27_577 VGND VPWR sky130_fd_sc_hd__tapvpwrvgnd_1
XFILLER_44_64 VGND VGND VPWR VPWR sky130_fd_sc_hd__decap_3
XFILLER_8_214 VGND VGND VPWR VPWR sky130_fd_sc_hd__decap_3
XFILLER_60_63 VGND VGND VPWR VPWR sky130_fd_sc_hd__decap_3
XFILLER_8_247 VGND VGND VPWR VPWR sky130_fd_sc_hd__decap_3
XFILLER_8_269 VGND VGND VPWR VPWR sky130_fd_sc_hd__decap_3
XFILLER_60_85 VGND VGND VPWR VPWR sky130_fd_sc_hd__decap_3
XFILLER_5_36 VGND VGND VPWR VPWR sky130_fd_sc_hd__decap_3
XFILLER_99_508 VGND VGND VPWR VPWR sky130_fd_sc_hd__decap_3
XFILLER_109_90 VGND VGND VPWR VPWR sky130_fd_sc_hd__decap_3
XFILLER_5_69 VGND VGND VPWR VPWR sky130_fd_sc_hd__decap_3
XFILLER_69_72 VGND VGND VPWR VPWR sky130_fd_sc_hd__decap_3
XFILLER_79_265 VGND VGND VPWR VPWR sky130_fd_sc_hd__decap_3
XFILLER_0_670 VGND VGND VPWR VPWR sky130_fd_sc_hd__fill_2
XFILLER_48_630 VGND VGND VPWR VPWR sky130_fd_sc_hd__decap_3
XFILLER_67_449 VGND VGND VPWR VPWR sky130_fd_sc_hd__decap_3
XFILLER_79_287 VGND VGND VPWR VPWR sky130_fd_sc_hd__decap_3
XFILLER_94_224 VGND VGND VPWR VPWR sky130_fd_sc_hd__decap_3
XFILLER_10_6 VGND VGND VPWR VPWR sky130_fd_sc_hd__decap_3
XFILLER_48_663 VGND VGND VPWR VPWR sky130_fd_sc_hd__decap_3
XFILLER_94_268 VGND VGND VPWR VPWR sky130_fd_sc_hd__decap_3
XFILLER_35_313 VGND VGND VPWR VPWR sky130_fd_sc_hd__fill_2
XFILLER_82_419 VGND VGND VPWR VPWR sky130_fd_sc_hd__fill_1
XFILLER_85_93 VGND VGND VPWR VPWR sky130_fd_sc_hd__decap_3
XFILLER_35_346 VGND VGND VPWR VPWR sky130_fd_sc_hd__decap_3
XFILLER_62_132 VGND VGND VPWR VPWR sky130_fd_sc_hd__decap_3
XFILLER_63_644 VGND VGND VPWR VPWR sky130_fd_sc_hd__decap_3
XFILLER_35_368 VGND VGND VPWR VPWR sky130_fd_sc_hd__decap_3
XTAP_TAPCELL_ROW_85_1269 VGND VPWR sky130_fd_sc_hd__tapvpwrvgnd_1
XFILLER_62_187 VGND VGND VPWR VPWR sky130_fd_sc_hd__decap_3
X_5710_ _7361_/Q hold912/X _5719_/S VGND VGND VPWR VPWR _6705_/D sky130_fd_sc_hd__mux2_2
XFILLER_93_3 VGND VGND VPWR VPWR sky130_fd_sc_hd__decap_3
X_6690_ _7384_/CLK _6690_/D VGND VGND VPWR VPWR _6690_/Q sky130_fd_sc_hd__dfxtp_2
X_5641_ _5641_/A VGND VGND VPWR VPWR _5641_/Y sky130_fd_sc_hd__inv_2
X_5572_ hold954/X _4960_/A _4961_/C VGND VGND VPWR VPWR _7045_/D sky130_fd_sc_hd__a21o_2
X_7311_ _7356_/CLK _7311_/D _6591_/Y VGND VGND VPWR VPWR _7311_/Q sky130_fd_sc_hd__dfrtp_2
X_7242_ _7338_/CLK _7242_/D _6522_/Y VGND VGND VPWR VPWR _7242_/Q sky130_fd_sc_hd__dfrtp_2
XFILLER_116_167 VGND VGND VPWR VPWR sky130_fd_sc_hd__fill_1
XFILLER_116_178 VGND VGND VPWR VPWR sky130_fd_sc_hd__decap_3
X_4454_ _4761_/B _4761_/C _4745_/A _4762_/B VGND VGND VPWR VPWR _4454_/X sky130_fd_sc_hd__a211o_2
XTAP_TAPCELL_ROW_96_1398 VGND VPWR sky130_fd_sc_hd__tapvpwrvgnd_1
X_7173_ _7365_/CLK _7173_/D _6453_/Y VGND VGND VPWR VPWR _7173_/Q sky130_fd_sc_hd__dfrtp_2
X_4385_ _7337_/Q _3945_/S _4428_/B1 _7145_/Q VGND VGND VPWR VPWR _4385_/X sky130_fd_sc_hd__a22o_2
X_3405_ _5129_/A _6983_/Q _3340_/C _4667_/B VGND VGND VPWR VPWR _3409_/D sky130_fd_sc_hd__o31a_2
XFILLER_105_15 VGND VGND VPWR VPWR sky130_fd_sc_hd__decap_3
XFILLER_112_340 VGND VGND VPWR VPWR sky130_fd_sc_hd__decap_3
XFILLER_98_552 VGND VGND VPWR VPWR sky130_fd_sc_hd__decap_3
XFILLER_100_513 VGND VGND VPWR VPWR sky130_fd_sc_hd__decap_3
XFILLER_105_48 VGND VGND VPWR VPWR sky130_fd_sc_hd__decap_3
XFILLER_112_373 VGND VGND VPWR VPWR sky130_fd_sc_hd__decap_3
XFILLER_85_246 VGND VGND VPWR VPWR sky130_fd_sc_hd__decap_3
X_5006_ _5114_/A _4626_/X _5003_/A _5033_/B2 VGND VGND VPWR VPWR _5006_/X sky130_fd_sc_hd__a22o_2
XFILLER_38_162 VGND VGND VPWR VPWR sky130_fd_sc_hd__decap_3
XFILLER_39_685 VGND VGND VPWR VPWR sky130_fd_sc_hd__decap_3
XFILLER_54_622 VGND VGND VPWR VPWR sky130_fd_sc_hd__decap_3
XFILLER_85_279 VGND VGND VPWR VPWR sky130_fd_sc_hd__fill_1
XFILLER_38_195 VGND VGND VPWR VPWR sky130_fd_sc_hd__fill_1
XFILLER_14_508 VGND VGND VPWR VPWR sky130_fd_sc_hd__decap_3
XFILLER_26_368 VGND VGND VPWR VPWR sky130_fd_sc_hd__decap_3
XFILLER_41_305 VGND VGND VPWR VPWR sky130_fd_sc_hd__decap_3
XFILLER_53_143 VGND VGND VPWR VPWR sky130_fd_sc_hd__decap_3
XFILLER_53_154 VGND VGND VPWR VPWR sky130_fd_sc_hd__decap_3
XFILLER_54_666 VGND VGND VPWR VPWR sky130_fd_sc_hd__decap_3
XFILLER_81_18 VGND VGND VPWR VPWR sky130_fd_sc_hd__decap_3
XFILLER_81_452 VGND VGND VPWR VPWR sky130_fd_sc_hd__decap_3
X_6957_ _6978_/CLK _6957_/D VGND VGND VPWR VPWR _6957_/Q sky130_fd_sc_hd__dfxtp_2
XFILLER_41_349 VGND VGND VPWR VPWR sky130_fd_sc_hd__decap_3
XFILLER_53_187 VGND VGND VPWR VPWR sky130_fd_sc_hd__decap_3
XFILLER_81_496 VGND VGND VPWR VPWR sky130_fd_sc_hd__decap_3
XTAP_TAPCELL_ROW_62_1000 VGND VPWR sky130_fd_sc_hd__tapvpwrvgnd_1
XTAP_TAPCELL_ROW_24_536 VGND VPWR sky130_fd_sc_hd__tapvpwrvgnd_1
XFILLER_14_12 VGND VGND VPWR VPWR sky130_fd_sc_hd__decap_3
X_6888_ _6965_/CLK _6888_/D VGND VGND VPWR VPWR _6888_/Q sky130_fd_sc_hd__dfxtp_2
XTAP_TAPCELL_ROW_52_878 VGND VPWR sky130_fd_sc_hd__tapvpwrvgnd_1
XFILLER_14_56 VGND VGND VPWR VPWR sky130_fd_sc_hd__decap_3
XFILLER_30_11 VGND VGND VPWR VPWR sky130_fd_sc_hd__decap_3
XFILLER_5_228 VGND VGND VPWR VPWR sky130_fd_sc_hd__decap_3
XFILLER_108_657 VGND VGND VPWR VPWR sky130_fd_sc_hd__decap_3
XFILLER_30_44 VGND VGND VPWR VPWR sky130_fd_sc_hd__fill_2
XFILLER_30_66 VGND VGND VPWR VPWR sky130_fd_sc_hd__decap_3
XFILLER_30_88 VGND VGND VPWR VPWR sky130_fd_sc_hd__decap_3
XFILLER_1_423 VGND VGND VPWR VPWR sky130_fd_sc_hd__decap_3
XFILLER_1_434 VGND VGND VPWR VPWR sky130_fd_sc_hd__decap_3
Xhold770 _6837_/Q VGND VGND VPWR VPWR _6837_/D sky130_fd_sc_hd__dlygate4sd3_1
Xhold781 _6793_/Q VGND VGND VPWR VPWR _6793_/D sky130_fd_sc_hd__dlygate4sd3_1
XFILLER_103_340 VGND VGND VPWR VPWR sky130_fd_sc_hd__fill_2
XFILLER_1_467 VGND VGND VPWR VPWR sky130_fd_sc_hd__decap_3
XFILLER_39_20 VGND VGND VPWR VPWR sky130_fd_sc_hd__fill_1
Xhold792 _6956_/Q VGND VGND VPWR VPWR _6956_/D sky130_fd_sc_hd__dlygate4sd3_1
XFILLER_1_489 VGND VGND VPWR VPWR sky130_fd_sc_hd__decap_3
XFILLER_39_64 VGND VGND VPWR VPWR sky130_fd_sc_hd__fill_2
XFILLER_76_246 VGND VGND VPWR VPWR sky130_fd_sc_hd__decap_3
XFILLER_76_268 VGND VGND VPWR VPWR sky130_fd_sc_hd__decap_3
XFILLER_64_419 VGND VGND VPWR VPWR sky130_fd_sc_hd__fill_1
XTAP_TAPCELL_ROW_4_294 VGND VPWR sky130_fd_sc_hd__tapvpwrvgnd_1
XFILLER_17_335 VGND VGND VPWR VPWR sky130_fd_sc_hd__fill_1
XFILLER_45_644 VGND VGND VPWR VPWR sky130_fd_sc_hd__decap_3
XFILLER_55_30 VGND VGND VPWR VPWR sky130_fd_sc_hd__decap_3
XFILLER_57_482 VGND VGND VPWR VPWR sky130_fd_sc_hd__decap_3
XFILLER_72_430 VGND VGND VPWR VPWR sky130_fd_sc_hd__decap_3
XFILLER_45_688 VGND VGND VPWR VPWR sky130_fd_sc_hd__decap_3
XFILLER_72_474 VGND VGND VPWR VPWR sky130_fd_sc_hd__fill_2
XFILLER_44_176 VGND VGND VPWR VPWR sky130_fd_sc_hd__decap_3
XFILLER_60_625 VGND VGND VPWR VPWR sky130_fd_sc_hd__decap_3
XFILLER_13_530 VGND VGND VPWR VPWR sky130_fd_sc_hd__decap_3
XFILLER_60_669 VGND VGND VPWR VPWR sky130_fd_sc_hd__decap_3
XFILLER_71_40 VGND VGND VPWR VPWR sky130_fd_sc_hd__decap_3
XFILLER_40_371 VGND VGND VPWR VPWR sky130_fd_sc_hd__decap_3
XFILLER_71_62 VGND VGND VPWR VPWR sky130_fd_sc_hd__decap_3
XFILLER_13_596 VGND VGND VPWR VPWR sky130_fd_sc_hd__fill_2
XFILLER_9_556 VGND VGND VPWR VPWR sky130_fd_sc_hd__decap_3
XFILLER_114_616 VGND VGND VPWR VPWR sky130_fd_sc_hd__decap_3
XFILLER_99_305 VGND VGND VPWR VPWR sky130_fd_sc_hd__decap_3
XFILLER_113_137 VGND VGND VPWR VPWR sky130_fd_sc_hd__decap_3
X_4170_ _4203_/A _4203_/B _4202_/A VGND VGND VPWR VPWR _4938_/B sky130_fd_sc_hd__and3_2
XFILLER_96_70 VGND VGND VPWR VPWR sky130_fd_sc_hd__decap_3
XFILLER_95_544 VGND VGND VPWR VPWR sky130_fd_sc_hd__decap_3
XFILLER_96_81 VGND VGND VPWR VPWR sky130_fd_sc_hd__decap_3
XFILLER_95_599 VGND VGND VPWR VPWR sky130_fd_sc_hd__decap_3
XFILLER_48_493 VGND VGND VPWR VPWR sky130_fd_sc_hd__fill_2
XFILLER_75_290 VGND VGND VPWR VPWR sky130_fd_sc_hd__decap_3
XFILLER_35_143 VGND VGND VPWR VPWR sky130_fd_sc_hd__decap_3
Xplace430 _3371_/Y VGND VGND VPWR VPWR _4159_/A2 sky130_fd_sc_hd__buf_2
X_6811_ _6929_/CLK _6811_/D VGND VGND VPWR VPWR _6811_/Q sky130_fd_sc_hd__dfxtp_2
XFILLER_35_187 VGND VGND VPWR VPWR sky130_fd_sc_hd__decap_3
XFILLER_51_647 VGND VGND VPWR VPWR sky130_fd_sc_hd__decap_3
Xplace441 _4467_/Y VGND VGND VPWR VPWR _5581_/S sky130_fd_sc_hd__buf_2
Xplace452 _6983_/Q VGND VGND VPWR VPWR _5670_/A sky130_fd_sc_hd__buf_2
XFILLER_50_135 VGND VGND VPWR VPWR sky130_fd_sc_hd__decap_3
X_6742_ _6977_/CLK _6742_/D VGND VGND VPWR VPWR _6742_/Q sky130_fd_sc_hd__dfxtp_2
X_3954_ _7363_/Q _4497_/A0 _3958_/S VGND VGND VPWR VPWR _7363_/D sky130_fd_sc_hd__mux2_2
XFILLER_50_168 VGND VGND VPWR VPWR sky130_fd_sc_hd__decap_3
X_6673_ _6674_/A VGND VGND VPWR VPWR _6673_/Y sky130_fd_sc_hd__inv_2
X_3885_ _3746_/X _3882_/X _3884_/X _3725_/X VGND VGND VPWR VPWR _3885_/X sky130_fd_sc_hd__a22o_2
XTAP_TAPCELL_ROW_21_506 VGND VPWR sky130_fd_sc_hd__tapvpwrvgnd_1
XFILLER_31_393 VGND VGND VPWR VPWR sky130_fd_sc_hd__decap_3
X_5624_ _5624_/A _5633_/B VGND VGND VPWR VPWR _7016_/D sky130_fd_sc_hd__or2_2
XTAP_TAPCELL_ROW_98_1427 VGND VPWR sky130_fd_sc_hd__tapvpwrvgnd_1
XFILLER_104_104 VGND VGND VPWR VPWR sky130_fd_sc_hd__fill_2
XFILLER_2_209 VGND VGND VPWR VPWR sky130_fd_sc_hd__fill_2
XFILLER_104_137 VGND VGND VPWR VPWR sky130_fd_sc_hd__decap_3
XFILLER_105_649 VGND VGND VPWR VPWR sky130_fd_sc_hd__decap_3
X_7225_ _7358_/CLK _7225_/D _6505_/Y VGND VGND VPWR VPWR _7225_/Q sky130_fd_sc_hd__dfrtp_2
X_4437_ _7022_/Q _4437_/A2 _4437_/B1 _7399_/Q _4436_/X VGND VGND VPWR VPWR _4437_/X
+ sky130_fd_sc_hd__a221o_2
XFILLER_116_47 VGND VGND VPWR VPWR sky130_fd_sc_hd__decap_3
X_7156_ clkload7/A _7156_/D _6436_/Y VGND VGND VPWR VPWR _7156_/Q sky130_fd_sc_hd__dfrtp_2
XFILLER_113_671 VGND VGND VPWR VPWR sky130_fd_sc_hd__fill_1
XFILLER_58_224 VGND VGND VPWR VPWR sky130_fd_sc_hd__decap_3
X_4368_ _5073_/A _4366_/X _5054_/A VGND VGND VPWR VPWR _4369_/B sky130_fd_sc_hd__a21oi_2
XFILLER_98_371 VGND VGND VPWR VPWR sky130_fd_sc_hd__decap_3
XFILLER_98_360 VGND VGND VPWR VPWR sky130_fd_sc_hd__decap_3
XFILLER_112_192 VGND VGND VPWR VPWR sky130_fd_sc_hd__decap_3
X_7087_ clkload7/A _7087_/D _6367_/Y VGND VGND VPWR VPWR _7087_/Q sky130_fd_sc_hd__dfstp_2
X_4299_ _3620_/A _4292_/X _4298_/X VGND VGND VPWR VPWR _5100_/B sky130_fd_sc_hd__a21o_2
X_3319_ _3378_/A _5646_/A _5647_/A _5647_/B VGND VGND VPWR VPWR _3319_/X sky130_fd_sc_hd__and4b_4
XFILLER_100_365 VGND VGND VPWR VPWR sky130_fd_sc_hd__fill_1
XFILLER_100_387 VGND VGND VPWR VPWR sky130_fd_sc_hd__decap_3
XTAP_TAPCELL_ROW_57_937 VGND VPWR sky130_fd_sc_hd__tapvpwrvgnd_1
XFILLER_100_398 VGND VGND VPWR VPWR sky130_fd_sc_hd__decap_3
XFILLER_26_121 VGND VGND VPWR VPWR sky130_fd_sc_hd__fill_2
XFILLER_73_249 VGND VGND VPWR VPWR sky130_fd_sc_hd__decap_3
XTAP_TAPCELL_ROW_107_1534 VGND VPWR sky130_fd_sc_hd__tapvpwrvgnd_1
XTAP_TAPCELL_ROW_1_264 VGND VPWR sky130_fd_sc_hd__tapvpwrvgnd_1
XFILLER_25_44 VGND VGND VPWR VPWR sky130_fd_sc_hd__decap_3
XFILLER_26_165 VGND VGND VPWR VPWR sky130_fd_sc_hd__decap_3
XFILLER_41_113 VGND VGND VPWR VPWR sky130_fd_sc_hd__decap_3
XFILLER_42_625 VGND VGND VPWR VPWR sky130_fd_sc_hd__decap_3
XFILLER_54_474 VGND VGND VPWR VPWR sky130_fd_sc_hd__fill_2
XFILLER_54_485 VGND VGND VPWR VPWR sky130_fd_sc_hd__decap_3
XFILLER_54_496 VGND VGND VPWR VPWR sky130_fd_sc_hd__decap_3
XTAP_TAPCELL_ROW_37_694 VGND VPWR sky130_fd_sc_hd__tapvpwrvgnd_1
XFILLER_25_77 VGND VGND VPWR VPWR sky130_fd_sc_hd__decap_3
XFILLER_42_669 VGND VGND VPWR VPWR sky130_fd_sc_hd__decap_3
XFILLER_22_371 VGND VGND VPWR VPWR sky130_fd_sc_hd__decap_3
XFILLER_25_99 VGND VGND VPWR VPWR sky130_fd_sc_hd__decap_3
XFILLER_10_544 VGND VGND VPWR VPWR sky130_fd_sc_hd__decap_3
XFILLER_41_32 VGND VGND VPWR VPWR sky130_fd_sc_hd__decap_3
XFILLER_108_443 VGND VGND VPWR VPWR sky130_fd_sc_hd__decap_3
XFILLER_104_660 VGND VGND VPWR VPWR sky130_fd_sc_hd__decap_3
XTAP_TAPCELL_ROW_9_364 VGND VPWR sky130_fd_sc_hd__tapvpwrvgnd_1
XFILLER_89_382 VGND VGND VPWR VPWR sky130_fd_sc_hd__decap_3
XFILLER_103_181 VGND VGND VPWR VPWR sky130_fd_sc_hd__decap_3
XFILLER_106_80 VGND VGND VPWR VPWR sky130_fd_sc_hd__decap_3
XFILLER_2_59 VGND VGND VPWR VPWR sky130_fd_sc_hd__decap_3
XFILLER_49_246 VGND VGND VPWR VPWR sky130_fd_sc_hd__decap_3
XFILLER_77_544 VGND VGND VPWR VPWR sky130_fd_sc_hd__decap_3
XFILLER_89_393 VGND VGND VPWR VPWR sky130_fd_sc_hd__decap_3
XFILLER_106_91 VGND VGND VPWR VPWR sky130_fd_sc_hd__decap_3
XFILLER_49_279 VGND VGND VPWR VPWR sky130_fd_sc_hd__fill_1
XFILLER_64_216 VGND VGND VPWR VPWR sky130_fd_sc_hd__decap_3
XFILLER_66_51 VGND VGND VPWR VPWR sky130_fd_sc_hd__decap_3
XFILLER_77_588 VGND VGND VPWR VPWR sky130_fd_sc_hd__fill_1
XFILLER_57_290 VGND VGND VPWR VPWR sky130_fd_sc_hd__decap_3
XFILLER_92_558 VGND VGND VPWR VPWR sky130_fd_sc_hd__decap_3
XFILLER_17_132 VGND VGND VPWR VPWR sky130_fd_sc_hd__decap_3
XFILLER_45_441 VGND VGND VPWR VPWR sky130_fd_sc_hd__decap_3
XFILLER_17_165 VGND VGND VPWR VPWR sky130_fd_sc_hd__decap_3
XFILLER_17_187 VGND VGND VPWR VPWR sky130_fd_sc_hd__decap_3
XFILLER_18_688 VGND VGND VPWR VPWR sky130_fd_sc_hd__decap_3
XFILLER_82_50 VGND VGND VPWR VPWR sky130_fd_sc_hd__decap_3
XFILLER_82_83 VGND VGND VPWR VPWR sky130_fd_sc_hd__fill_1
XTAP_TAPCELL_ROW_82_1239 VGND VPWR sky130_fd_sc_hd__tapvpwrvgnd_1
XFILLER_32_179 VGND VGND VPWR VPWR sky130_fd_sc_hd__decap_3
XFILLER_82_94 VGND VGND VPWR VPWR sky130_fd_sc_hd__decap_3
XFILLER_13_393 VGND VGND VPWR VPWR sky130_fd_sc_hd__fill_2
XFILLER_41_691 VGND VGND VPWR VPWR sky130_fd_sc_hd__fill_1
X_3670_ _3682_/A _3669_/X _3709_/B1 VGND VGND VPWR VPWR _3670_/X sky130_fd_sc_hd__a21o_2
XFILLER_9_386 VGND VGND VPWR VPWR sky130_fd_sc_hd__decap_3
XFILLER_9_364 VGND VGND VPWR VPWR sky130_fd_sc_hd__fill_1
XFILLER_56_3 VGND VGND VPWR VPWR sky130_fd_sc_hd__decap_3
X_5340_ _5340_/A0 _5079_/X _5360_/S VGND VGND VPWR VPWR _7161_/D sky130_fd_sc_hd__mux2_2
XFILLER_99_102 VGND VGND VPWR VPWR sky130_fd_sc_hd__fill_2
XFILLER_114_424 VGND VGND VPWR VPWR sky130_fd_sc_hd__decap_3
XTAP_TAPCELL_ROW_93_1368 VGND VPWR sky130_fd_sc_hd__tapvpwrvgnd_1
XFILLER_99_113 VGND VGND VPWR VPWR sky130_fd_sc_hd__decap_3
XFILLER_102_619 VGND VGND VPWR VPWR sky130_fd_sc_hd__decap_3
X_7010_ _7266_/CLK _7010_/D _6290_/Y VGND VGND VPWR VPWR _7010_/Q sky130_fd_sc_hd__dfrtp_2
X_4222_ _7356_/Q _4272_/B _4221_/X VGND VGND VPWR VPWR _4222_/X sky130_fd_sc_hd__a21o_2
XFILLER_101_107 VGND VGND VPWR VPWR sky130_fd_sc_hd__decap_3
XFILLER_68_533 VGND VGND VPWR VPWR sky130_fd_sc_hd__decap_3
XFILLER_68_566 VGND VGND VPWR VPWR sky130_fd_sc_hd__decap_3
XFILLER_95_330 VGND VGND VPWR VPWR sky130_fd_sc_hd__fill_2
X_4153_ _7298_/Q _4879_/S _4267_/B1 _7170_/Q _4152_/X VGND VGND VPWR VPWR _4153_/X
+ sky130_fd_sc_hd__a221o_2
XFILLER_110_663 VGND VGND VPWR VPWR sky130_fd_sc_hd__decap_3
XFILLER_28_419 VGND VGND VPWR VPWR sky130_fd_sc_hd__fill_1
XFILLER_55_216 VGND VGND VPWR VPWR sky130_fd_sc_hd__fill_1
XFILLER_68_599 VGND VGND VPWR VPWR sky130_fd_sc_hd__decap_3
XFILLER_83_525 VGND VGND VPWR VPWR sky130_fd_sc_hd__decap_3
XFILLER_95_363 VGND VGND VPWR VPWR sky130_fd_sc_hd__decap_3
X_4084_ _7302_/Q _4499_/S _4083_/X _4429_/C1 VGND VGND VPWR VPWR _4084_/X sky130_fd_sc_hd__a211o_2
XFILLER_36_441 VGND VGND VPWR VPWR sky130_fd_sc_hd__decap_3
XFILLER_23_102 VGND VGND VPWR VPWR sky130_fd_sc_hd__fill_1
XFILLER_23_113 VGND VGND VPWR VPWR sky130_fd_sc_hd__decap_3
XFILLER_51_411 VGND VGND VPWR VPWR sky130_fd_sc_hd__decap_3
XFILLER_23_135 VGND VGND VPWR VPWR sky130_fd_sc_hd__decap_3
XFILLER_51_444 VGND VGND VPWR VPWR sky130_fd_sc_hd__decap_3
XFILLER_63_293 VGND VGND VPWR VPWR sky130_fd_sc_hd__decap_3
Xplace282 _3925_/A2 VGND VGND VPWR VPWR _3767_/A2 sky130_fd_sc_hd__buf_2
Xplace271 _3912_/B1 VGND VGND VPWR VPWR _3869_/B1 sky130_fd_sc_hd__buf_2
X_4986_ _5003_/A _5003_/B _4626_/X VGND VGND VPWR VPWR _4987_/B sky130_fd_sc_hd__a21oi_2
XFILLER_11_308 VGND VGND VPWR VPWR sky130_fd_sc_hd__decap_3
XFILLER_23_157 VGND VGND VPWR VPWR sky130_fd_sc_hd__decap_3
Xplace293 _3891_/A2 VGND VGND VPWR VPWR _3889_/A2 sky130_fd_sc_hd__buf_2
X_6725_ _6975_/CLK _6725_/D VGND VGND VPWR VPWR _6725_/Q sky130_fd_sc_hd__dfxtp_2
X_3937_ _7371_/Q _4480_/A0 _3945_/S VGND VGND VPWR VPWR _7371_/D sky130_fd_sc_hd__mux2_2
XTAP_TAPCELL_ROW_62_995 VGND VPWR sky130_fd_sc_hd__tapvpwrvgnd_1
XTAP_TAPCELL_ROW_34_664 VGND VPWR sky130_fd_sc_hd__tapvpwrvgnd_1
XTAP_TAPCELL_ROW_102_1475 VGND VPWR sky130_fd_sc_hd__tapvpwrvgnd_1
XFILLER_31_190 VGND VGND VPWR VPWR sky130_fd_sc_hd__decap_3
X_6656_ _6670_/A VGND VGND VPWR VPWR _6656_/Y sky130_fd_sc_hd__inv_2
X_3868_ hold974/X _3909_/A2 _3867_/X VGND VGND VPWR VPWR _7384_/D sky130_fd_sc_hd__a21o_2
XFILLER_11_24 VGND VGND VPWR VPWR sky130_fd_sc_hd__decap_3
X_6587_ _6587_/A VGND VGND VPWR VPWR _6587_/Y sky130_fd_sc_hd__inv_2
X_5607_ _5607_/A _5634_/B VGND VGND VPWR VPWR _7024_/D sky130_fd_sc_hd__and2_2
X_3799_ _6909_/Q _3892_/A2 _3893_/B1 _6853_/Q VGND VGND VPWR VPWR _3799_/X sky130_fd_sc_hd__a22o_2
XFILLER_105_402 VGND VGND VPWR VPWR sky130_fd_sc_hd__decap_3
XFILLER_11_57 VGND VGND VPWR VPWR sky130_fd_sc_hd__decap_3
XFILLER_105_435 VGND VGND VPWR VPWR sky130_fd_sc_hd__decap_3
XFILLER_11_79 VGND VGND VPWR VPWR sky130_fd_sc_hd__decap_3
XFILLER_87_39 VGND VGND VPWR VPWR sky130_fd_sc_hd__decap_3
X_7208_ _7365_/CLK _7208_/D _6488_/Y VGND VGND VPWR VPWR _7208_/Q sky130_fd_sc_hd__dfrtp_2
XFILLER_59_511 VGND VGND VPWR VPWR sky130_fd_sc_hd__decap_3
XTAP_TAPCELL_ROW_6_323 VGND VPWR sky130_fd_sc_hd__tapvpwrvgnd_1
XFILLER_99_691 VGND VGND VPWR VPWR sky130_fd_sc_hd__fill_1
X_7139_ _7363_/CLK _7139_/D _6419_/Y VGND VGND VPWR VPWR _7139_/Q sky130_fd_sc_hd__dfrtp_2
XFILLER_101_663 VGND VGND VPWR VPWR sky130_fd_sc_hd__decap_3
XFILLER_101_685 VGND VGND VPWR VPWR sky130_fd_sc_hd__decap_3
XFILLER_19_408 VGND VGND VPWR VPWR sky130_fd_sc_hd__decap_3
XFILLER_86_374 VGND VGND VPWR VPWR sky130_fd_sc_hd__decap_3
XFILLER_100_162 VGND VGND VPWR VPWR sky130_fd_sc_hd__decap_3
XFILLER_36_21 VGND VGND VPWR VPWR sky130_fd_sc_hd__decap_3
XFILLER_74_536 VGND VGND VPWR VPWR sky130_fd_sc_hd__decap_3
XFILLER_27_430 VGND VGND VPWR VPWR sky130_fd_sc_hd__fill_1
XFILLER_27_452 VGND VGND VPWR VPWR sky130_fd_sc_hd__decap_3
XFILLER_36_43 VGND VGND VPWR VPWR sky130_fd_sc_hd__decap_3
XFILLER_61_208 VGND VGND VPWR VPWR sky130_fd_sc_hd__decap_3
XFILLER_15_625 VGND VGND VPWR VPWR sky130_fd_sc_hd__fill_1
XFILLER_36_76 VGND VGND VPWR VPWR sky130_fd_sc_hd__decap_3
XFILLER_54_271 VGND VGND VPWR VPWR sky130_fd_sc_hd__decap_3
XFILLER_82_580 VGND VGND VPWR VPWR sky130_fd_sc_hd__decap_3
XTAP_TAPCELL_ROW_68_1072 VGND VPWR sky130_fd_sc_hd__tapvpwrvgnd_1
XFILLER_14_135 VGND VGND VPWR VPWR sky130_fd_sc_hd__decap_3
XFILLER_14_179 VGND VGND VPWR VPWR sky130_fd_sc_hd__decap_3
XFILLER_30_617 VGND VGND VPWR VPWR sky130_fd_sc_hd__decap_3
XFILLER_30_639 VGND VGND VPWR VPWR sky130_fd_sc_hd__decap_3
XFILLER_42_499 VGND VGND VPWR VPWR sky130_fd_sc_hd__decap_3
XFILLER_22_190 VGND VGND VPWR VPWR sky130_fd_sc_hd__decap_3
XFILLER_10_374 VGND VGND VPWR VPWR sky130_fd_sc_hd__decap_3
XFILLER_6_312 VGND VGND VPWR VPWR sky130_fd_sc_hd__decap_3
XFILLER_108_295 VGND VGND VPWR VPWR sky130_fd_sc_hd__decap_3
XFILLER_97_617 VGND VGND VPWR VPWR sky130_fd_sc_hd__decap_3
XFILLER_96_116 VGND VGND VPWR VPWR sky130_fd_sc_hd__fill_1
XFILLER_96_127 VGND VGND VPWR VPWR sky130_fd_sc_hd__fill_1
XFILLER_111_449 VGND VGND VPWR VPWR sky130_fd_sc_hd__decap_3
XFILLER_77_72 VGND VGND VPWR VPWR sky130_fd_sc_hd__decap_3
XFILLER_37_205 VGND VGND VPWR VPWR sky130_fd_sc_hd__decap_3
XFILLER_77_83 VGND VGND VPWR VPWR sky130_fd_sc_hd__decap_3
XFILLER_77_385 VGND VGND VPWR VPWR sky130_fd_sc_hd__decap_3
XFILLER_77_396 VGND VGND VPWR VPWR sky130_fd_sc_hd__decap_3
XFILLER_92_333 VGND VGND VPWR VPWR sky130_fd_sc_hd__decap_3
XFILLER_18_430 VGND VGND VPWR VPWR sky130_fd_sc_hd__fill_1
XFILLER_18_452 VGND VGND VPWR VPWR sky130_fd_sc_hd__decap_3
XFILLER_65_558 VGND VGND VPWR VPWR sky130_fd_sc_hd__fill_2
XFILLER_80_506 VGND VGND VPWR VPWR sky130_fd_sc_hd__decap_3
XFILLER_93_60 VGND VGND VPWR VPWR sky130_fd_sc_hd__decap_3
XFILLER_80_539 VGND VGND VPWR VPWR sky130_fd_sc_hd__decap_3
XFILLER_92_399 VGND VGND VPWR VPWR sky130_fd_sc_hd__decap_3
XFILLER_33_444 VGND VGND VPWR VPWR sky130_fd_sc_hd__decap_3
X_4840_ _4903_/B _4903_/C _4903_/A VGND VGND VPWR VPWR _4888_/B sky130_fd_sc_hd__a21oi_2
XFILLER_21_617 VGND VGND VPWR VPWR sky130_fd_sc_hd__decap_3
XFILLER_60_296 VGND VGND VPWR VPWR sky130_fd_sc_hd__decap_3
X_6510_ _6608_/A VGND VGND VPWR VPWR _6510_/Y sky130_fd_sc_hd__inv_2
X_4771_ _4836_/S _7005_/D _4760_/Y _4770_/X VGND VGND VPWR VPWR _4771_/X sky130_fd_sc_hd__o211a_2
XTAP_TAPCELL_ROW_31_623 VGND VPWR sky130_fd_sc_hd__tapvpwrvgnd_1
X_6441_ _6604_/A VGND VGND VPWR VPWR _6441_/Y sky130_fd_sc_hd__inv_2
XFILLER_9_172 VGND VGND VPWR VPWR sky130_fd_sc_hd__decap_3
X_6372_ _6567_/A VGND VGND VPWR VPWR _6372_/Y sky130_fd_sc_hd__inv_2
XTAP_TAPCELL_ROW_11_380 VGND VPWR sky130_fd_sc_hd__tapvpwrvgnd_1
X_5323_ _5323_/A0 _4945_/X _5323_/S VGND VGND VPWR VPWR _7169_/D sky130_fd_sc_hd__mux2_2
X_3584_ _3424_/S _3583_/X _5648_/B VGND VGND VPWR VPWR _3586_/D sky130_fd_sc_hd__a21oi_2
XFILLER_114_221 VGND VGND VPWR VPWR sky130_fd_sc_hd__decap_3
XFILLER_102_427 VGND VGND VPWR VPWR sky130_fd_sc_hd__decap_3
XFILLER_87_116 VGND VGND VPWR VPWR sky130_fd_sc_hd__decap_3
XFILLER_88_639 VGND VGND VPWR VPWR sky130_fd_sc_hd__decap_3
XFILLER_87_149 VGND VGND VPWR VPWR sky130_fd_sc_hd__fill_2
X_4205_ _4205_/A _4205_/B _4205_/C VGND VGND VPWR VPWR _4205_/X sky130_fd_sc_hd__and3_2
XFILLER_68_352 VGND VGND VPWR VPWR sky130_fd_sc_hd__decap_3
XFILLER_68_374 VGND VGND VPWR VPWR sky130_fd_sc_hd__decap_3
XFILLER_96_683 VGND VGND VPWR VPWR sky130_fd_sc_hd__decap_3
X_4136_ _7235_/Q _3318_/B _4865_/S _7299_/Q _4135_/X VGND VGND VPWR VPWR _4136_/X
+ sky130_fd_sc_hd__a221o_2
XFILLER_110_471 VGND VGND VPWR VPWR sky130_fd_sc_hd__decap_3
XFILLER_113_15 VGND VGND VPWR VPWR sky130_fd_sc_hd__decap_3
XFILLER_56_547 VGND VGND VPWR VPWR sky130_fd_sc_hd__fill_2
XFILLER_83_311 VGND VGND VPWR VPWR sky130_fd_sc_hd__decap_3
XFILLER_95_193 VGND VGND VPWR VPWR sky130_fd_sc_hd__decap_3
XTAP_TAPCELL_ROW_39_723 VGND VPWR sky130_fd_sc_hd__tapvpwrvgnd_1
XFILLER_113_48 VGND VGND VPWR VPWR sky130_fd_sc_hd__decap_3
XFILLER_28_249 VGND VGND VPWR VPWR sky130_fd_sc_hd__decap_3
X_4067_ _4068_/A _4082_/A VGND VGND VPWR VPWR _4744_/B sky130_fd_sc_hd__and2_2
XTAP_TAPCELL_ROW_104_1504 VGND VPWR sky130_fd_sc_hd__tapvpwrvgnd_1
XTAP_TAPCELL_ROW_19_480 VGND VPWR sky130_fd_sc_hd__tapvpwrvgnd_1
XFILLER_11_105 VGND VGND VPWR VPWR sky130_fd_sc_hd__decap_3
XFILLER_12_606 VGND VGND VPWR VPWR sky130_fd_sc_hd__decap_3
XFILLER_11_116 VGND VGND VPWR VPWR sky130_fd_sc_hd__decap_3
XFILLER_51_296 VGND VGND VPWR VPWR sky130_fd_sc_hd__decap_3
X_4969_ _4968_/Y _4969_/B _4969_/C VGND VGND VPWR VPWR _4969_/X sky130_fd_sc_hd__and3b_2
XFILLER_22_12 VGND VGND VPWR VPWR sky130_fd_sc_hd__decap_3
X_6708_ _7230_/CLK _6708_/D VGND VGND VPWR VPWR _6708_/Q sky130_fd_sc_hd__dfxtp_2
XFILLER_22_45 VGND VGND VPWR VPWR sky130_fd_sc_hd__fill_1
XFILLER_22_56 VGND VGND VPWR VPWR sky130_fd_sc_hd__decap_3
X_6639_ _6640_/A VGND VGND VPWR VPWR _6639_/Y sky130_fd_sc_hd__inv_2
XFILLER_3_315 VGND VGND VPWR VPWR sky130_fd_sc_hd__decap_3
XTAP_TAPCELL_ROW_115_1633 VGND VPWR sky130_fd_sc_hd__tapvpwrvgnd_1
XFILLER_3_337 VGND VGND VPWR VPWR sky130_fd_sc_hd__decap_3
XFILLER_78_105 VGND VGND VPWR VPWR sky130_fd_sc_hd__decap_3
Xoutput480 _5652_/Y VGND VGND VPWR VPWR alu_result_out[27] sky130_fd_sc_hd__clkdlybuf4s25_1
XFILLER_105_298 VGND VGND VPWR VPWR sky130_fd_sc_hd__fill_2
XFILLER_78_138 VGND VGND VPWR VPWR sky130_fd_sc_hd__fill_2
Xoutput491 _5651_/Y VGND VGND VPWR VPWR alu_result_out[8] sky130_fd_sc_hd__clkdlybuf4s25_1
XPHY_EDGE_ROW_110_Right_110 VGND VGND VPWR VPWR sky130_fd_sc_hd__decap_3
XFILLER_19_205 VGND VGND VPWR VPWR sky130_fd_sc_hd__decap_3
XFILLER_59_352 VGND VGND VPWR VPWR sky130_fd_sc_hd__decap_3
XFILLER_59_363 VGND VGND VPWR VPWR sky130_fd_sc_hd__decap_3
XFILLER_93_119 VGND VGND VPWR VPWR sky130_fd_sc_hd__decap_3
XFILLER_19_216 VGND VGND VPWR VPWR sky130_fd_sc_hd__decap_3
XFILLER_59_396 VGND VGND VPWR VPWR sky130_fd_sc_hd__decap_3
XFILLER_74_300 VGND VGND VPWR VPWR sky130_fd_sc_hd__decap_3
XFILLER_86_182 VGND VGND VPWR VPWR sky130_fd_sc_hd__decap_3
XFILLER_47_75 VGND VGND VPWR VPWR sky130_fd_sc_hd__decap_3
XFILLER_27_260 VGND VGND VPWR VPWR sky130_fd_sc_hd__decap_3
XFILLER_74_377 VGND VGND VPWR VPWR sky130_fd_sc_hd__decap_3
XFILLER_103_81 VGND VGND VPWR VPWR sky130_fd_sc_hd__decap_3
XFILLER_27_293 VGND VGND VPWR VPWR sky130_fd_sc_hd__decap_3
XFILLER_42_230 VGND VGND VPWR VPWR sky130_fd_sc_hd__decap_3
XFILLER_63_30 VGND VGND VPWR VPWR sky130_fd_sc_hd__fill_1
XFILLER_63_41 VGND VGND VPWR VPWR sky130_fd_sc_hd__decap_3
XFILLER_42_274 VGND VGND VPWR VPWR sky130_fd_sc_hd__fill_2
XFILLER_8_14 VGND VGND VPWR VPWR sky130_fd_sc_hd__decap_3
XFILLER_8_47 VGND VGND VPWR VPWR sky130_fd_sc_hd__decap_3
XFILLER_11_683 VGND VGND VPWR VPWR sky130_fd_sc_hd__fill_1
XFILLER_10_171 VGND VGND VPWR VPWR sky130_fd_sc_hd__decap_3
XFILLER_116_519 VGND VGND VPWR VPWR sky130_fd_sc_hd__decap_3
XFILLER_6_153 VGND VGND VPWR VPWR sky130_fd_sc_hd__decap_3
XFILLER_7_665 VGND VGND VPWR VPWR sky130_fd_sc_hd__decap_3
XFILLER_7_676 VGND VGND VPWR VPWR sky130_fd_sc_hd__decap_3
Xwire552 _3749_/Y VGND VGND VPWR VPWR wire552/X sky130_fd_sc_hd__clkbuf_2
XFILLER_40_6 VGND VGND VPWR VPWR sky130_fd_sc_hd__decap_3
XFILLER_6_197 VGND VGND VPWR VPWR sky130_fd_sc_hd__decap_3
XFILLER_88_82 VGND VGND VPWR VPWR sky130_fd_sc_hd__fill_2
XTAP_TAPCELL_ROW_90_1327 VGND VPWR sky130_fd_sc_hd__tapvpwrvgnd_1
XFILLER_2_392 VGND VGND VPWR VPWR sky130_fd_sc_hd__decap_3
XFILLER_69_149 VGND VGND VPWR VPWR sky130_fd_sc_hd__fill_1
XFILLER_97_447 VGND VGND VPWR VPWR sky130_fd_sc_hd__fill_1
XFILLER_111_279 VGND VGND VPWR VPWR sky130_fd_sc_hd__fill_1
XFILLER_78_661 VGND VGND VPWR VPWR sky130_fd_sc_hd__decap_3
XFILLER_38_536 VGND VGND VPWR VPWR sky130_fd_sc_hd__decap_3
XFILLER_38_547 VGND VGND VPWR VPWR sky130_fd_sc_hd__decap_3
XFILLER_65_311 VGND VGND VPWR VPWR sky130_fd_sc_hd__decap_3
XFILLER_65_355 VGND VGND VPWR VPWR sky130_fd_sc_hd__decap_3
XFILLER_77_193 VGND VGND VPWR VPWR sky130_fd_sc_hd__decap_3
XFILLER_92_141 VGND VGND VPWR VPWR sky130_fd_sc_hd__decap_3
XFILLER_93_653 VGND VGND VPWR VPWR sky130_fd_sc_hd__decap_3
X_6990_ _7338_/CLK _6990_/D _6270_/Y VGND VGND VPWR VPWR _6990_/Q sky130_fd_sc_hd__dfrtp_2
XFILLER_65_399 VGND VGND VPWR VPWR sky130_fd_sc_hd__decap_3
XFILLER_92_163 VGND VGND VPWR VPWR sky130_fd_sc_hd__decap_3
XFILLER_33_263 VGND VGND VPWR VPWR sky130_fd_sc_hd__decap_3
XFILLER_61_561 VGND VGND VPWR VPWR sky130_fd_sc_hd__decap_3
XFILLER_33_296 VGND VGND VPWR VPWR sky130_fd_sc_hd__fill_1
X_4823_ _4823_/A0 _4822_/X _4865_/S VGND VGND VPWR VPWR _7272_/D sky130_fd_sc_hd__mux2_2
XTAP_TAPCELL_ROW_44_781 VGND VPWR sky130_fd_sc_hd__tapvpwrvgnd_1
X_3705_ _7400_/Q _3704_/X _4832_/A VGND VGND VPWR VPWR _7400_/D sky130_fd_sc_hd__mux2_2
X_4685_ _6996_/Q _4668_/X _4928_/B _4684_/X VGND VGND VPWR VPWR _4858_/B sky130_fd_sc_hd__a31o_2
XFILLER_108_15 VGND VGND VPWR VPWR sky130_fd_sc_hd__decap_3
X_6424_ _6675_/A VGND VGND VPWR VPWR _6424_/Y sky130_fd_sc_hd__inv_2
X_3636_ _3636_/A _3636_/B VGND VGND VPWR VPWR _3636_/Y sky130_fd_sc_hd__nor2_2
XFILLER_108_59 VGND VGND VPWR VPWR sky130_fd_sc_hd__decap_3
XFILLER_115_530 VGND VGND VPWR VPWR sky130_fd_sc_hd__decap_3
X_6355_ _6385_/A VGND VGND VPWR VPWR _6355_/Y sky130_fd_sc_hd__inv_2
X_3567_ _7221_/Q _4331_/A2 _4528_/B _7034_/Q _3566_/X VGND VGND VPWR VPWR _3567_/X
+ sky130_fd_sc_hd__a221o_2
XFILLER_115_585 VGND VGND VPWR VPWR sky130_fd_sc_hd__decap_3
XFILLER_88_403 VGND VGND VPWR VPWR sky130_fd_sc_hd__decap_3
X_6286_ _6288_/A VGND VGND VPWR VPWR _6286_/Y sky130_fd_sc_hd__inv_2
X_5306_ _5306_/A0 _4806_/X _5327_/S VGND VGND VPWR VPWR _7177_/D sky130_fd_sc_hd__mux2_2
XFILLER_88_436 VGND VGND VPWR VPWR sky130_fd_sc_hd__decap_3
X_3498_ _3442_/A _3442_/B _3449_/B VGND VGND VPWR VPWR _5152_/B sky130_fd_sc_hd__a21oi_2
XFILLER_102_268 VGND VGND VPWR VPWR sky130_fd_sc_hd__decap_3
XFILLER_69_650 VGND VGND VPWR VPWR sky130_fd_sc_hd__fill_2
XFILLER_75_108 VGND VGND VPWR VPWR sky130_fd_sc_hd__fill_1
XTAP_TAPCELL_ROW_110_1574 VGND VPWR sky130_fd_sc_hd__tapvpwrvgnd_1
XFILLER_68_171 VGND VGND VPWR VPWR sky130_fd_sc_hd__decap_3
XFILLER_75_119 VGND VGND VPWR VPWR sky130_fd_sc_hd__decap_3
XFILLER_84_29 VGND VGND VPWR VPWR sky130_fd_sc_hd__decap_3
XFILLER_96_480 VGND VGND VPWR VPWR sky130_fd_sc_hd__decap_3
XFILLER_17_12 VGND VGND VPWR VPWR sky130_fd_sc_hd__decap_3
X_5099_ _5099_/A _5100_/A VGND VGND VPWR VPWR _5099_/X sky130_fd_sc_hd__or2_2
X_4119_ _7236_/Q _3318_/B _4196_/A2 _7396_/Q _4118_/X VGND VGND VPWR VPWR _4119_/X
+ sky130_fd_sc_hd__a221o_2
XFILLER_17_45 VGND VGND VPWR VPWR sky130_fd_sc_hd__decap_3
XFILLER_44_528 VGND VGND VPWR VPWR sky130_fd_sc_hd__decap_3
XFILLER_71_314 VGND VGND VPWR VPWR sky130_fd_sc_hd__fill_1
XFILLER_83_152 VGND VGND VPWR VPWR sky130_fd_sc_hd__decap_3
XTAP_TAPCELL_ROW_65_1031 VGND VPWR sky130_fd_sc_hd__tapvpwrvgnd_1
XFILLER_12_403 VGND VGND VPWR VPWR sky130_fd_sc_hd__decap_3
XFILLER_24_274 VGND VGND VPWR VPWR sky130_fd_sc_hd__decap_3
XFILLER_33_99 VGND VGND VPWR VPWR sky130_fd_sc_hd__decap_3
XFILLER_4_635 VGND VGND VPWR VPWR sky130_fd_sc_hd__decap_3
XFILLER_106_530 VGND VGND VPWR VPWR sky130_fd_sc_hd__fill_2
XFILLER_3_134 VGND VGND VPWR VPWR sky130_fd_sc_hd__decap_3
XFILLER_4_657 VGND VGND VPWR VPWR sky130_fd_sc_hd__decap_3
XTAP_TAPCELL_ROW_76_1160 VGND VPWR sky130_fd_sc_hd__tapvpwrvgnd_1
XFILLER_3_167 VGND VGND VPWR VPWR sky130_fd_sc_hd__fill_1
XFILLER_79_414 VGND VGND VPWR VPWR sky130_fd_sc_hd__decap_3
XFILLER_58_41 VGND VGND VPWR VPWR sky130_fd_sc_hd__decap_3
XFILLER_58_63 VGND VGND VPWR VPWR sky130_fd_sc_hd__decap_3
XFILLER_58_85 VGND VGND VPWR VPWR sky130_fd_sc_hd__decap_3
XFILLER_59_193 VGND VGND VPWR VPWR sky130_fd_sc_hd__decap_3
XFILLER_114_80 VGND VGND VPWR VPWR sky130_fd_sc_hd__decap_3
XFILLER_114_91 VGND VGND VPWR VPWR sky130_fd_sc_hd__decap_3
XFILLER_35_539 VGND VGND VPWR VPWR sky130_fd_sc_hd__fill_1
XFILLER_47_366 VGND VGND VPWR VPWR sky130_fd_sc_hd__decap_3
XFILLER_62_303 VGND VGND VPWR VPWR sky130_fd_sc_hd__decap_3
XFILLER_47_399 VGND VGND VPWR VPWR sky130_fd_sc_hd__decap_3
XFILLER_62_336 VGND VGND VPWR VPWR sky130_fd_sc_hd__decap_3
XFILLER_74_73 VGND VGND VPWR VPWR sky130_fd_sc_hd__decap_3
XFILLER_90_645 VGND VGND VPWR VPWR sky130_fd_sc_hd__fill_1
XFILLER_90_667 VGND VGND VPWR VPWR sky130_fd_sc_hd__decap_3
XFILLER_15_252 VGND VGND VPWR VPWR sky130_fd_sc_hd__decap_3
XFILLER_43_561 VGND VGND VPWR VPWR sky130_fd_sc_hd__decap_3
XFILLER_15_296 VGND VGND VPWR VPWR sky130_fd_sc_hd__decap_3
XFILLER_30_200 VGND VGND VPWR VPWR sky130_fd_sc_hd__decap_3
XFILLER_88_6 VGND VGND VPWR VPWR sky130_fd_sc_hd__decap_3
XFILLER_90_50 VGND VGND VPWR VPWR sky130_fd_sc_hd__fill_1
XTAP_TAPCELL_ROW_41_740 VGND VPWR sky130_fd_sc_hd__tapvpwrvgnd_1
XFILLER_90_94 VGND VGND VPWR VPWR sky130_fd_sc_hd__decap_3
XFILLER_30_299 VGND VGND VPWR VPWR sky130_fd_sc_hd__decap_3
X_4470_ _3346_/A _3927_/X _4466_/Y _4469_/X VGND VGND VPWR VPWR _4470_/X sky130_fd_sc_hd__a31o_2
XFILLER_7_495 VGND VGND VPWR VPWR sky130_fd_sc_hd__decap_3
X_3421_ _4537_/B _3421_/B _3421_/C VGND VGND VPWR VPWR _4289_/B sky130_fd_sc_hd__or3_4
XFILLER_99_81 VGND VGND VPWR VPWR sky130_fd_sc_hd__decap_3
X_3352_ _3420_/A _5642_/B VGND VGND VPWR VPWR _3469_/B sky130_fd_sc_hd__nor2_2
XFILLER_112_533 VGND VGND VPWR VPWR sky130_fd_sc_hd__decap_3
XFILLER_97_222 VGND VGND VPWR VPWR sky130_fd_sc_hd__fill_2
XFILLER_58_609 VGND VGND VPWR VPWR sky130_fd_sc_hd__decap_3
XFILLER_85_417 VGND VGND VPWR VPWR sky130_fd_sc_hd__decap_3
XFILLER_97_255 VGND VGND VPWR VPWR sky130_fd_sc_hd__decap_3
XFILLER_66_631 VGND VGND VPWR VPWR sky130_fd_sc_hd__decap_3
XFILLER_78_480 VGND VGND VPWR VPWR sky130_fd_sc_hd__decap_3
XFILLER_97_299 VGND VGND VPWR VPWR sky130_fd_sc_hd__decap_3
Xhold1107 _7332_/Q VGND VGND VPWR VPWR _4495_/A0 sky130_fd_sc_hd__dlygate4sd3_1
Xhold1118 _7336_/Q VGND VGND VPWR VPWR _4486_/A0 sky130_fd_sc_hd__dlygate4sd3_1
Xhold1129 _7143_/Q VGND VGND VPWR VPWR _5379_/A0 sky130_fd_sc_hd__dlygate4sd3_1
X_5022_ _3548_/X _5017_/Y _5020_/X _5021_/X VGND VGND VPWR VPWR _5661_/A sky130_fd_sc_hd__o211a_2
XFILLER_65_141 VGND VGND VPWR VPWR sky130_fd_sc_hd__decap_3
XTAP_TAPCELL_ROW_49_840 VGND VPWR sky130_fd_sc_hd__tapvpwrvgnd_1
XFILLER_38_377 VGND VGND VPWR VPWR sky130_fd_sc_hd__decap_3
XFILLER_66_675 VGND VGND VPWR VPWR sky130_fd_sc_hd__decap_3
XFILLER_81_623 VGND VGND VPWR VPWR sky130_fd_sc_hd__decap_3
XFILLER_93_461 VGND VGND VPWR VPWR sky130_fd_sc_hd__decap_3
XFILLER_65_196 VGND VGND VPWR VPWR sky130_fd_sc_hd__decap_3
XFILLER_80_133 VGND VGND VPWR VPWR sky130_fd_sc_hd__decap_3
X_6973_ _6978_/CLK _6973_/D VGND VGND VPWR VPWR _6973_/Q sky130_fd_sc_hd__dfxtp_2
XFILLER_0_92 VGND VGND VPWR VPWR sky130_fd_sc_hd__decap_3
XFILLER_80_144 VGND VGND VPWR VPWR sky130_fd_sc_hd__decap_3
XFILLER_81_667 VGND VGND VPWR VPWR sky130_fd_sc_hd__decap_3
XFILLER_110_27 VGND VGND VPWR VPWR sky130_fd_sc_hd__fill_1
XFILLER_110_38 VGND VGND VPWR VPWR sky130_fd_sc_hd__decap_3
XFILLER_21_211 VGND VGND VPWR VPWR sky130_fd_sc_hd__decap_3
XFILLER_80_177 VGND VGND VPWR VPWR sky130_fd_sc_hd__decap_3
XFILLER_21_255 VGND VGND VPWR VPWR sky130_fd_sc_hd__decap_3
X_4806_ _3346_/A _3701_/X _4799_/X _4805_/X VGND VGND VPWR VPWR _4806_/X sky130_fd_sc_hd__a31o_2
XFILLER_21_277 VGND VGND VPWR VPWR sky130_fd_sc_hd__decap_3
XFILLER_9_90 VGND VGND VPWR VPWR sky130_fd_sc_hd__decap_3
XFILLER_21_299 VGND VGND VPWR VPWR sky130_fd_sc_hd__decap_3
X_4737_ _7005_/Q _4775_/A _7006_/Q VGND VGND VPWR VPWR _4738_/B sky130_fd_sc_hd__a21oi_2
XFILLER_107_316 VGND VGND VPWR VPWR sky130_fd_sc_hd__decap_3
X_4668_ _4908_/A _4896_/A VGND VGND VPWR VPWR _4668_/X sky130_fd_sc_hd__and2_2
Xhold930 _6710_/Q VGND VGND VPWR VPWR hold930/X sky130_fd_sc_hd__dlygate4sd3_1
X_6407_ _6570_/A VGND VGND VPWR VPWR _6407_/Y sky130_fd_sc_hd__inv_2
X_3619_ _3620_/A _3620_/C _4292_/B VGND VGND VPWR VPWR _3619_/Y sky130_fd_sc_hd__o21ai_2
XFILLER_103_500 VGND VGND VPWR VPWR sky130_fd_sc_hd__decap_3
XFILLER_88_200 VGND VGND VPWR VPWR sky130_fd_sc_hd__decap_3
X_7387_ _7387_/CLK _7387_/D _6667_/Y VGND VGND VPWR VPWR _7387_/Q sky130_fd_sc_hd__dfrtp_2
Xhold963 _7042_/Q VGND VGND VPWR VPWR hold963/X sky130_fd_sc_hd__dlygate4sd3_1
Xhold952 _7043_/Q VGND VGND VPWR VPWR hold952/X sky130_fd_sc_hd__dlygate4sd3_1
Xhold941 _7033_/Q VGND VGND VPWR VPWR _5589_/A sky130_fd_sc_hd__dlygate4sd3_1
X_4599_ _7281_/Q _5142_/A0 _4601_/S VGND VGND VPWR VPWR _7281_/D sky130_fd_sc_hd__mux2_2
XFILLER_0_104 VGND VGND VPWR VPWR sky130_fd_sc_hd__decap_3
XFILLER_0_126 VGND VGND VPWR VPWR sky130_fd_sc_hd__decap_3
XFILLER_103_511 VGND VGND VPWR VPWR sky130_fd_sc_hd__decap_3
XFILLER_115_393 VGND VGND VPWR VPWR sky130_fd_sc_hd__decap_3
XFILLER_1_638 VGND VGND VPWR VPWR sky130_fd_sc_hd__decap_3
XFILLER_88_233 VGND VGND VPWR VPWR sky130_fd_sc_hd__fill_2
Xhold996 _6716_/Q VGND VGND VPWR VPWR hold996/X sky130_fd_sc_hd__dlygate4sd3_1
Xhold985 _7054_/Q VGND VGND VPWR VPWR hold985/X sky130_fd_sc_hd__dlygate4sd3_1
Xhold974 _7384_/Q VGND VGND VPWR VPWR hold974/X sky130_fd_sc_hd__dlygate4sd3_1
X_6338_ _6568_/A VGND VGND VPWR VPWR _6338_/Y sky130_fd_sc_hd__inv_2
XFILLER_76_417 VGND VGND VPWR VPWR sky130_fd_sc_hd__decap_3
X_6269_ _6553_/A VGND VGND VPWR VPWR _6269_/Y sky130_fd_sc_hd__inv_2
XFILLER_103_588 VGND VGND VPWR VPWR sky130_fd_sc_hd__fill_2
XFILLER_57_620 VGND VGND VPWR VPWR sky130_fd_sc_hd__decap_3
XFILLER_28_66 VGND VGND VPWR VPWR sky130_fd_sc_hd__decap_3
XFILLER_29_333 VGND VGND VPWR VPWR sky130_fd_sc_hd__decap_3
XFILLER_56_130 VGND VGND VPWR VPWR sky130_fd_sc_hd__fill_2
XFILLER_57_653 VGND VGND VPWR VPWR sky130_fd_sc_hd__decap_3
XFILLER_28_88 VGND VGND VPWR VPWR sky130_fd_sc_hd__decap_3
XFILLER_56_141 VGND VGND VPWR VPWR sky130_fd_sc_hd__decap_3
XFILLER_56_163 VGND VGND VPWR VPWR sky130_fd_sc_hd__decap_3
XFILLER_84_483 VGND VGND VPWR VPWR sky130_fd_sc_hd__fill_2
XFILLER_29_399 VGND VGND VPWR VPWR sky130_fd_sc_hd__decap_3
XFILLER_44_336 VGND VGND VPWR VPWR sky130_fd_sc_hd__decap_3
XFILLER_72_645 VGND VGND VPWR VPWR sky130_fd_sc_hd__fill_2
XFILLER_32_509 VGND VGND VPWR VPWR sky130_fd_sc_hd__decap_3
XFILLER_44_21 VGND VGND VPWR VPWR sky130_fd_sc_hd__decap_3
XTAP_TAPCELL_ROW_27_578 VGND VPWR sky130_fd_sc_hd__tapvpwrvgnd_1
XFILLER_12_200 VGND VGND VPWR VPWR sky130_fd_sc_hd__decap_3
XFILLER_25_594 VGND VGND VPWR VPWR sky130_fd_sc_hd__decap_3
XFILLER_12_233 VGND VGND VPWR VPWR sky130_fd_sc_hd__decap_3
XFILLER_100_71 VGND VGND VPWR VPWR sky130_fd_sc_hd__decap_3
XFILLER_100_82 VGND VGND VPWR VPWR sky130_fd_sc_hd__fill_2
XFILLER_40_586 VGND VGND VPWR VPWR sky130_fd_sc_hd__fill_2
XFILLER_60_20 VGND VGND VPWR VPWR sky130_fd_sc_hd__decap_3
XFILLER_4_421 VGND VGND VPWR VPWR sky130_fd_sc_hd__decap_3
XFILLER_5_15 VGND VGND VPWR VPWR sky130_fd_sc_hd__decap_3
XFILLER_113_308 VGND VGND VPWR VPWR sky130_fd_sc_hd__decap_3
XFILLER_5_48 VGND VGND VPWR VPWR sky130_fd_sc_hd__decap_3
XFILLER_69_51 VGND VGND VPWR VPWR sky130_fd_sc_hd__decap_3
XFILLER_69_84 VGND VGND VPWR VPWR sky130_fd_sc_hd__decap_3
XFILLER_79_211 VGND VGND VPWR VPWR sky130_fd_sc_hd__decap_3
XFILLER_79_222 VGND VGND VPWR VPWR sky130_fd_sc_hd__fill_2
XFILLER_79_233 VGND VGND VPWR VPWR sky130_fd_sc_hd__decap_3
XFILLER_0_660 VGND VGND VPWR VPWR sky130_fd_sc_hd__fill_2
XFILLER_39_108 VGND VGND VPWR VPWR sky130_fd_sc_hd__decap_3
XFILLER_39_119 VGND VGND VPWR VPWR sky130_fd_sc_hd__decap_3
XFILLER_67_417 VGND VGND VPWR VPWR sky130_fd_sc_hd__decap_3
XFILLER_79_277 VGND VGND VPWR VPWR sky130_fd_sc_hd__decap_3
XFILLER_79_299 VGND VGND VPWR VPWR sky130_fd_sc_hd__fill_2
XFILLER_48_642 VGND VGND VPWR VPWR sky130_fd_sc_hd__fill_2
XPHY_EDGE_ROW_13_Right_13 VGND VGND VPWR VPWR sky130_fd_sc_hd__decap_3
XFILLER_48_675 VGND VGND VPWR VPWR sky130_fd_sc_hd__decap_3
XFILLER_63_612 VGND VGND VPWR VPWR sky130_fd_sc_hd__fill_1
XFILLER_63_623 VGND VGND VPWR VPWR sky130_fd_sc_hd__decap_3
XFILLER_75_461 VGND VGND VPWR VPWR sky130_fd_sc_hd__decap_3
XFILLER_62_100 VGND VGND VPWR VPWR sky130_fd_sc_hd__decap_3
XFILLER_63_656 VGND VGND VPWR VPWR sky130_fd_sc_hd__decap_3
XFILLER_75_494 VGND VGND VPWR VPWR sky130_fd_sc_hd__decap_3
XFILLER_50_306 VGND VGND VPWR VPWR sky130_fd_sc_hd__fill_2
XFILLER_62_144 VGND VGND VPWR VPWR sky130_fd_sc_hd__decap_3
XFILLER_62_166 VGND VGND VPWR VPWR sky130_fd_sc_hd__decap_3
XFILLER_90_475 VGND VGND VPWR VPWR sky130_fd_sc_hd__fill_1
X_3970_ _7355_/Q _4513_/A0 _3989_/S VGND VGND VPWR VPWR _7355_/D sky130_fd_sc_hd__mux2_2
XFILLER_16_583 VGND VGND VPWR VPWR sky130_fd_sc_hd__decap_3
XFILLER_43_380 VGND VGND VPWR VPWR sky130_fd_sc_hd__decap_3
XFILLER_86_3 VGND VGND VPWR VPWR sky130_fd_sc_hd__decap_3
X_5640_ _5640_/A _5640_/B VGND VGND VPWR VPWR _5640_/Y sky130_fd_sc_hd__nor2_2
X_5571_ _5571_/A1 _4909_/A _4944_/C VGND VGND VPWR VPWR _7046_/D sky130_fd_sc_hd__a21o_2
XPHY_EDGE_ROW_22_Right_22 VGND VGND VPWR VPWR sky130_fd_sc_hd__decap_3
XFILLER_116_113 VGND VGND VPWR VPWR sky130_fd_sc_hd__decap_3
X_7310_ _7374_/CLK _7310_/D _6590_/Y VGND VGND VPWR VPWR _7310_/Q sky130_fd_sc_hd__dfrtp_2
X_4522_ _7318_/Q _7286_/Q _4530_/S VGND VGND VPWR VPWR _7318_/D sky130_fd_sc_hd__mux2_2
XFILLER_116_135 VGND VGND VPWR VPWR sky130_fd_sc_hd__decap_3
XFILLER_7_281 VGND VGND VPWR VPWR sky130_fd_sc_hd__decap_3
X_7241_ _7338_/CLK _7241_/D _6521_/Y VGND VGND VPWR VPWR _7241_/Q sky130_fd_sc_hd__dfrtp_2
X_4453_ _4453_/A VGND VGND VPWR VPWR _4762_/B sky130_fd_sc_hd__inv_2
XTAP_TAPCELL_ROW_96_1399 VGND VPWR sky130_fd_sc_hd__tapvpwrvgnd_1
X_7172_ _7264_/CLK _7172_/D _6452_/Y VGND VGND VPWR VPWR _7172_/Q sky130_fd_sc_hd__dfrtp_2
X_4384_ _4384_/A _4968_/A _4384_/C VGND VGND VPWR VPWR _4778_/B sky130_fd_sc_hd__nand3_2
XFILLER_98_531 VGND VGND VPWR VPWR sky130_fd_sc_hd__fill_1
XFILLER_112_352 VGND VGND VPWR VPWR sky130_fd_sc_hd__decap_3
X_3335_ _3319_/X _5238_/B _3329_/Y _3339_/C1 VGND VGND VPWR VPWR _3442_/A sky130_fd_sc_hd__a211o_2
XFILLER_98_564 VGND VGND VPWR VPWR sky130_fd_sc_hd__decap_3
XFILLER_100_525 VGND VGND VPWR VPWR sky130_fd_sc_hd__decap_3
XFILLER_105_27 VGND VGND VPWR VPWR sky130_fd_sc_hd__decap_3
XPHY_EDGE_ROW_31_Right_31 VGND VGND VPWR VPWR sky130_fd_sc_hd__decap_3
XFILLER_38_130 VGND VGND VPWR VPWR sky130_fd_sc_hd__decap_3
XFILLER_39_653 VGND VGND VPWR VPWR sky130_fd_sc_hd__decap_3
X_5005_ _5004_/A _5004_/B _5020_/A VGND VGND VPWR VPWR _5005_/Y sky130_fd_sc_hd__a21oi_2
XFILLER_38_141 VGND VGND VPWR VPWR sky130_fd_sc_hd__decap_3
XFILLER_54_601 VGND VGND VPWR VPWR sky130_fd_sc_hd__decap_3
XFILLER_26_336 VGND VGND VPWR VPWR sky130_fd_sc_hd__decap_3
XFILLER_38_174 VGND VGND VPWR VPWR sky130_fd_sc_hd__decap_3
XFILLER_53_100 VGND VGND VPWR VPWR sky130_fd_sc_hd__decap_3
XFILLER_54_634 VGND VGND VPWR VPWR sky130_fd_sc_hd__decap_3
XFILLER_54_645 VGND VGND VPWR VPWR sky130_fd_sc_hd__decap_3
XFILLER_93_291 VGND VGND VPWR VPWR sky130_fd_sc_hd__decap_3
XFILLER_53_166 VGND VGND VPWR VPWR sky130_fd_sc_hd__fill_2
XFILLER_54_678 VGND VGND VPWR VPWR sky130_fd_sc_hd__decap_3
XFILLER_81_464 VGND VGND VPWR VPWR sky130_fd_sc_hd__decap_3
X_6956_ _6976_/CLK _6956_/D VGND VGND VPWR VPWR _6956_/Q sky130_fd_sc_hd__dfxtp_2
XFILLER_41_317 VGND VGND VPWR VPWR sky130_fd_sc_hd__decap_3
XTAP_TAPCELL_ROW_62_1001 VGND VPWR sky130_fd_sc_hd__tapvpwrvgnd_1
XFILLER_14_24 VGND VGND VPWR VPWR sky130_fd_sc_hd__decap_3
XFILLER_14_35 VGND VGND VPWR VPWR sky130_fd_sc_hd__decap_3
XFILLER_22_542 VGND VGND VPWR VPWR sky130_fd_sc_hd__decap_3
X_6887_ _6931_/CLK _6887_/D VGND VGND VPWR VPWR _6887_/Q sky130_fd_sc_hd__dfxtp_2
XTAP_TAPCELL_ROW_24_537 VGND VPWR sky130_fd_sc_hd__tapvpwrvgnd_1
XFILLER_22_575 VGND VGND VPWR VPWR sky130_fd_sc_hd__decap_3
XTAP_TAPCELL_ROW_52_879 VGND VPWR sky130_fd_sc_hd__tapvpwrvgnd_1
XPHY_EDGE_ROW_40_Right_40 VGND VGND VPWR VPWR sky130_fd_sc_hd__decap_3
XFILLER_22_597 VGND VGND VPWR VPWR sky130_fd_sc_hd__decap_3
XFILLER_30_23 VGND VGND VPWR VPWR sky130_fd_sc_hd__decap_3
XFILLER_107_113 VGND VGND VPWR VPWR sky130_fd_sc_hd__decap_3
XFILLER_108_669 VGND VGND VPWR VPWR sky130_fd_sc_hd__decap_3
XFILLER_1_402 VGND VGND VPWR VPWR sky130_fd_sc_hd__decap_3
Xhold760 _6844_/Q VGND VGND VPWR VPWR _6844_/D sky130_fd_sc_hd__dlygate4sd3_1
Xhold771 _6863_/Q VGND VGND VPWR VPWR _6863_/D sky130_fd_sc_hd__dlygate4sd3_1
Xhold782 _6791_/Q VGND VGND VPWR VPWR _6791_/D sky130_fd_sc_hd__dlygate4sd3_1
XTAP_TAPCELL_ROW_73_1130 VGND VPWR sky130_fd_sc_hd__tapvpwrvgnd_1
XFILLER_115_190 VGND VGND VPWR VPWR sky130_fd_sc_hd__decap_3
XFILLER_1_446 VGND VGND VPWR VPWR sky130_fd_sc_hd__fill_2
XFILLER_89_564 VGND VGND VPWR VPWR sky130_fd_sc_hd__decap_3
XFILLER_89_575 VGND VGND VPWR VPWR sky130_fd_sc_hd__fill_2
Xhold793 _6833_/Q VGND VGND VPWR VPWR _6833_/D sky130_fd_sc_hd__dlygate4sd3_1
XFILLER_103_374 VGND VGND VPWR VPWR sky130_fd_sc_hd__decap_3
XFILLER_39_43 VGND VGND VPWR VPWR sky130_fd_sc_hd__decap_3
XFILLER_49_439 VGND VGND VPWR VPWR sky130_fd_sc_hd__decap_3
XFILLER_103_396 VGND VGND VPWR VPWR sky130_fd_sc_hd__fill_2
XFILLER_39_87 VGND VGND VPWR VPWR sky130_fd_sc_hd__decap_3
XFILLER_45_601 VGND VGND VPWR VPWR sky130_fd_sc_hd__decap_3
XFILLER_45_612 VGND VGND VPWR VPWR sky130_fd_sc_hd__decap_3
XFILLER_17_314 VGND VGND VPWR VPWR sky130_fd_sc_hd__decap_3
XFILLER_29_196 VGND VGND VPWR VPWR sky130_fd_sc_hd__decap_3
XFILLER_44_111 VGND VGND VPWR VPWR sky130_fd_sc_hd__fill_2
XFILLER_45_623 VGND VGND VPWR VPWR sky130_fd_sc_hd__decap_3
XFILLER_84_291 VGND VGND VPWR VPWR sky130_fd_sc_hd__decap_3
XFILLER_91_239 VGND VGND VPWR VPWR sky130_fd_sc_hd__fill_2
XTAP_TAPCELL_ROW_4_295 VGND VPWR sky130_fd_sc_hd__tapvpwrvgnd_1
XFILLER_45_656 VGND VGND VPWR VPWR sky130_fd_sc_hd__decap_3
XFILLER_55_75 VGND VGND VPWR VPWR sky130_fd_sc_hd__decap_3
XFILLER_60_604 VGND VGND VPWR VPWR sky130_fd_sc_hd__decap_3
XFILLER_72_453 VGND VGND VPWR VPWR sky130_fd_sc_hd__decap_3
XFILLER_32_306 VGND VGND VPWR VPWR sky130_fd_sc_hd__fill_2
XFILLER_32_317 VGND VGND VPWR VPWR sky130_fd_sc_hd__decap_3
XFILLER_44_166 VGND VGND VPWR VPWR sky130_fd_sc_hd__fill_1
XFILLER_44_188 VGND VGND VPWR VPWR sky130_fd_sc_hd__decap_3
XFILLER_60_637 VGND VGND VPWR VPWR sky130_fd_sc_hd__decap_3
XFILLER_60_648 VGND VGND VPWR VPWR sky130_fd_sc_hd__decap_3
XFILLER_111_81 VGND VGND VPWR VPWR sky130_fd_sc_hd__decap_3
XFILLER_13_542 VGND VGND VPWR VPWR sky130_fd_sc_hd__decap_3
XFILLER_13_586 VGND VGND VPWR VPWR sky130_fd_sc_hd__fill_1
XFILLER_71_52 VGND VGND VPWR VPWR sky130_fd_sc_hd__decap_3
XFILLER_71_74 VGND VGND VPWR VPWR sky130_fd_sc_hd__fill_1
XFILLER_40_383 VGND VGND VPWR VPWR sky130_fd_sc_hd__decap_3
XFILLER_72_9 VGND VGND VPWR VPWR sky130_fd_sc_hd__decap_3
XFILLER_114_628 VGND VGND VPWR VPWR sky130_fd_sc_hd__decap_3
XFILLER_107_691 VGND VGND VPWR VPWR sky130_fd_sc_hd__fill_1
XFILLER_113_105 VGND VGND VPWR VPWR sky130_fd_sc_hd__decap_3
XFILLER_113_116 VGND VGND VPWR VPWR sky130_fd_sc_hd__decap_3
XFILLER_113_149 VGND VGND VPWR VPWR sky130_fd_sc_hd__decap_3
XFILLER_67_225 VGND VGND VPWR VPWR sky130_fd_sc_hd__decap_3
XFILLER_67_247 VGND VGND VPWR VPWR sky130_fd_sc_hd__decap_3
XFILLER_95_567 VGND VGND VPWR VPWR sky130_fd_sc_hd__decap_3
XFILLER_48_472 VGND VGND VPWR VPWR sky130_fd_sc_hd__decap_3
XFILLER_82_206 VGND VGND VPWR VPWR sky130_fd_sc_hd__decap_3
XFILLER_48_483 VGND VGND VPWR VPWR sky130_fd_sc_hd__fill_1
XFILLER_82_239 VGND VGND VPWR VPWR sky130_fd_sc_hd__decap_3
XFILLER_35_155 VGND VGND VPWR VPWR sky130_fd_sc_hd__decap_3
XFILLER_51_604 VGND VGND VPWR VPWR sky130_fd_sc_hd__decap_3
XFILLER_63_442 VGND VGND VPWR VPWR sky130_fd_sc_hd__decap_3
Xplace420 _3968_/S VGND VGND VPWR VPWR _3962_/S sky130_fd_sc_hd__buf_2
Xplace431 _3368_/Y VGND VGND VPWR VPWR _3394_/A sky130_fd_sc_hd__buf_2
X_6810_ _6977_/CLK _6810_/D VGND VGND VPWR VPWR _6810_/Q sky130_fd_sc_hd__dfxtp_2
XFILLER_50_103 VGND VGND VPWR VPWR sky130_fd_sc_hd__decap_3
XFILLER_51_626 VGND VGND VPWR VPWR sky130_fd_sc_hd__decap_3
XFILLER_90_272 VGND VGND VPWR VPWR sky130_fd_sc_hd__fill_2
Xplace442 _4667_/B VGND VGND VPWR VPWR _5634_/B sky130_fd_sc_hd__buf_2
Xplace453 _6982_/Q VGND VGND VPWR VPWR _5129_/A sky130_fd_sc_hd__buf_2
XFILLER_35_199 VGND VGND VPWR VPWR sky130_fd_sc_hd__decap_3
XFILLER_51_659 VGND VGND VPWR VPWR sky130_fd_sc_hd__decap_3
XFILLER_90_294 VGND VGND VPWR VPWR sky130_fd_sc_hd__fill_1
X_6741_ _6978_/CLK _6741_/D VGND VGND VPWR VPWR _6741_/Q sky130_fd_sc_hd__dfxtp_2
X_6672_ _6672_/A VGND VGND VPWR VPWR _6672_/Y sky130_fd_sc_hd__inv_2
X_3884_ _6824_/Q _3884_/A2 _3913_/B1 _6809_/Q _3883_/X VGND VGND VPWR VPWR _3884_/X
+ sky130_fd_sc_hd__a221o_2
XTAP_TAPCELL_ROW_21_507 VGND VPWR sky130_fd_sc_hd__tapvpwrvgnd_1
XFILLER_31_372 VGND VGND VPWR VPWR sky130_fd_sc_hd__decap_3
XTAP_TAPCELL_ROW_98_1428 VGND VPWR sky130_fd_sc_hd__tapvpwrvgnd_1
XFILLER_105_617 VGND VGND VPWR VPWR sky130_fd_sc_hd__decap_3
X_4505_ _4505_/A0 _7295_/Q _4505_/S VGND VGND VPWR VPWR _7327_/D sky130_fd_sc_hd__mux2_2
XFILLER_6_80 VGND VGND VPWR VPWR sky130_fd_sc_hd__decap_3
XFILLER_6_91 VGND VGND VPWR VPWR sky130_fd_sc_hd__decap_3
X_7224_ clkload5/A _7224_/D _6504_/Y VGND VGND VPWR VPWR _7224_/Q sky130_fd_sc_hd__dfrtp_2
X_4436_ _7303_/Q _4879_/S _4436_/B1 _7175_/Q _4435_/X VGND VGND VPWR VPWR _4436_/X
+ sky130_fd_sc_hd__a221o_2
XFILLER_104_149 VGND VGND VPWR VPWR sky130_fd_sc_hd__decap_3
XFILLER_113_650 VGND VGND VPWR VPWR sky130_fd_sc_hd__decap_3
X_7155_ clkload5/A _7155_/D _6435_/Y VGND VGND VPWR VPWR _7155_/Q sky130_fd_sc_hd__dfrtp_2
X_4367_ _4367_/A _4367_/B _4367_/C VGND VGND VPWR VPWR _5054_/A sky130_fd_sc_hd__and3_2
XFILLER_58_203 VGND VGND VPWR VPWR sky130_fd_sc_hd__decap_3
XFILLER_86_501 VGND VGND VPWR VPWR sky130_fd_sc_hd__decap_3
X_3318_ _3403_/A _3318_/B VGND VGND VPWR VPWR _5647_/B sky130_fd_sc_hd__nand2_2
XFILLER_98_383 VGND VGND VPWR VPWR sky130_fd_sc_hd__decap_3
XFILLER_112_171 VGND VGND VPWR VPWR sky130_fd_sc_hd__decap_3
XFILLER_58_236 VGND VGND VPWR VPWR sky130_fd_sc_hd__fill_2
XFILLER_58_247 VGND VGND VPWR VPWR sky130_fd_sc_hd__decap_3
X_7086_ _7266_/CLK _7086_/D _6366_/Y VGND VGND VPWR VPWR _7086_/Q sky130_fd_sc_hd__dfrtp_2
X_4298_ _3620_/C _4292_/X _4293_/X _4297_/Y VGND VGND VPWR VPWR _4298_/X sky130_fd_sc_hd__a211o_2
XFILLER_46_409 VGND VGND VPWR VPWR sky130_fd_sc_hd__decap_3
XFILLER_86_578 VGND VGND VPWR VPWR sky130_fd_sc_hd__decap_3
XFILLER_86_589 VGND VGND VPWR VPWR sky130_fd_sc_hd__decap_3
XFILLER_26_100 VGND VGND VPWR VPWR sky130_fd_sc_hd__decap_3
XFILLER_27_634 VGND VGND VPWR VPWR sky130_fd_sc_hd__decap_3
XFILLER_39_494 VGND VGND VPWR VPWR sky130_fd_sc_hd__decap_3
XFILLER_66_280 VGND VGND VPWR VPWR sky130_fd_sc_hd__decap_3
XFILLER_73_228 VGND VGND VPWR VPWR sky130_fd_sc_hd__decap_3
XFILLER_92_18 VGND VGND VPWR VPWR sky130_fd_sc_hd__decap_3
XTAP_TAPCELL_ROW_57_938 VGND VPWR sky130_fd_sc_hd__tapvpwrvgnd_1
XFILLER_92_29 VGND VGND VPWR VPWR sky130_fd_sc_hd__decap_3
XTAP_TAPCELL_ROW_1_265 VGND VPWR sky130_fd_sc_hd__tapvpwrvgnd_1
XTAP_TAPCELL_ROW_107_1535 VGND VPWR sky130_fd_sc_hd__tapvpwrvgnd_1
XFILLER_26_177 VGND VGND VPWR VPWR sky130_fd_sc_hd__decap_3
XFILLER_41_103 VGND VGND VPWR VPWR sky130_fd_sc_hd__fill_2
XFILLER_42_637 VGND VGND VPWR VPWR sky130_fd_sc_hd__decap_3
XFILLER_14_339 VGND VGND VPWR VPWR sky130_fd_sc_hd__decap_3
XFILLER_41_125 VGND VGND VPWR VPWR sky130_fd_sc_hd__decap_3
XFILLER_42_648 VGND VGND VPWR VPWR sky130_fd_sc_hd__decap_3
X_6939_ _7005_/CLK _6939_/D VGND VGND VPWR VPWR _6939_/Q sky130_fd_sc_hd__dfxtp_2
XTAP_TAPCELL_ROW_37_695 VGND VPWR sky130_fd_sc_hd__tapvpwrvgnd_1
XFILLER_41_11 VGND VGND VPWR VPWR sky130_fd_sc_hd__decap_3
XFILLER_50_681 VGND VGND VPWR VPWR sky130_fd_sc_hd__decap_3
XFILLER_108_411 VGND VGND VPWR VPWR sky130_fd_sc_hd__fill_1
XFILLER_10_556 VGND VGND VPWR VPWR sky130_fd_sc_hd__decap_3
XFILLER_10_578 VGND VGND VPWR VPWR sky130_fd_sc_hd__decap_3
XFILLER_41_44 VGND VGND VPWR VPWR sky130_fd_sc_hd__decap_3
XFILLER_6_549 VGND VGND VPWR VPWR sky130_fd_sc_hd__decap_3
XFILLER_108_477 VGND VGND VPWR VPWR sky130_fd_sc_hd__decap_3
XFILLER_111_609 VGND VGND VPWR VPWR sky130_fd_sc_hd__decap_3
XFILLER_96_309 VGND VGND VPWR VPWR sky130_fd_sc_hd__decap_3
Xhold590 _6922_/Q VGND VGND VPWR VPWR _6922_/D sky130_fd_sc_hd__dlygate4sd3_1
XTAP_TAPCELL_ROW_9_365 VGND VPWR sky130_fd_sc_hd__tapvpwrvgnd_1
XTAP_TAPCELL_ROW_9_354 VGND VPWR sky130_fd_sc_hd__tapvpwrvgnd_1
XFILLER_104_672 VGND VGND VPWR VPWR sky130_fd_sc_hd__decap_3
XFILLER_110_119 VGND VGND VPWR VPWR sky130_fd_sc_hd__fill_1
XFILLER_77_501 VGND VGND VPWR VPWR sky130_fd_sc_hd__decap_3
XFILLER_77_523 VGND VGND VPWR VPWR sky130_fd_sc_hd__decap_3
XFILLER_103_193 VGND VGND VPWR VPWR sky130_fd_sc_hd__decap_3
XFILLER_2_38 VGND VGND VPWR VPWR sky130_fd_sc_hd__decap_3
XFILLER_49_225 VGND VGND VPWR VPWR sky130_fd_sc_hd__decap_3
XFILLER_77_556 VGND VGND VPWR VPWR sky130_fd_sc_hd__decap_3
XFILLER_37_409 VGND VGND VPWR VPWR sky130_fd_sc_hd__fill_1
XFILLER_49_258 VGND VGND VPWR VPWR sky130_fd_sc_hd__decap_3
XFILLER_92_504 VGND VGND VPWR VPWR sky130_fd_sc_hd__decap_3
XFILLER_18_645 VGND VGND VPWR VPWR sky130_fd_sc_hd__decap_3
XFILLER_64_228 VGND VGND VPWR VPWR sky130_fd_sc_hd__decap_3
XFILLER_92_526 VGND VGND VPWR VPWR sky130_fd_sc_hd__decap_3
XFILLER_17_144 VGND VGND VPWR VPWR sky130_fd_sc_hd__decap_3
XFILLER_32_114 VGND VGND VPWR VPWR sky130_fd_sc_hd__fill_2
XFILLER_33_615 VGND VGND VPWR VPWR sky130_fd_sc_hd__fill_1
XFILLER_72_250 VGND VGND VPWR VPWR sky130_fd_sc_hd__fill_2
XFILLER_17_199 VGND VGND VPWR VPWR sky130_fd_sc_hd__decap_3
XFILLER_32_136 VGND VGND VPWR VPWR sky130_fd_sc_hd__decap_3
XFILLER_32_147 VGND VGND VPWR VPWR sky130_fd_sc_hd__fill_2
XFILLER_72_283 VGND VGND VPWR VPWR sky130_fd_sc_hd__decap_3
XFILLER_82_62 VGND VGND VPWR VPWR sky130_fd_sc_hd__decap_3
XFILLER_20_309 VGND VGND VPWR VPWR sky130_fd_sc_hd__fill_2
XFILLER_32_158 VGND VGND VPWR VPWR sky130_fd_sc_hd__decap_3
XFILLER_13_383 VGND VGND VPWR VPWR sky130_fd_sc_hd__decap_3
XFILLER_40_180 VGND VGND VPWR VPWR sky130_fd_sc_hd__decap_3
XFILLER_70_6 VGND VGND VPWR VPWR sky130_fd_sc_hd__decap_3
X_5270_ _5270_/A0 _5040_/X _5292_/S VGND VGND VPWR VPWR _7195_/D sky130_fd_sc_hd__mux2_2
XFILLER_49_3 VGND VGND VPWR VPWR sky130_fd_sc_hd__decap_3
X_4221_ _7228_/Q _4469_/A3 _4503_/S _7041_/Q _4220_/X VGND VGND VPWR VPWR _4221_/X
+ sky130_fd_sc_hd__a221o_2
XTAP_TAPCELL_ROW_93_1369 VGND VPWR sky130_fd_sc_hd__tapvpwrvgnd_1
XFILLER_99_169 VGND VGND VPWR VPWR sky130_fd_sc_hd__decap_3
XFILLER_99_158 VGND VGND VPWR VPWR sky130_fd_sc_hd__fill_2
XFILLER_110_631 VGND VGND VPWR VPWR sky130_fd_sc_hd__decap_3
X_4152_ _7106_/Q _4351_/A2 _4195_/A2 _7138_/Q VGND VGND VPWR VPWR _4152_/X sky130_fd_sc_hd__a22o_2
XFILLER_110_675 VGND VGND VPWR VPWR sky130_fd_sc_hd__decap_3
XFILLER_68_578 VGND VGND VPWR VPWR sky130_fd_sc_hd__decap_3
XFILLER_68_589 VGND VGND VPWR VPWR sky130_fd_sc_hd__fill_1
XFILLER_95_375 VGND VGND VPWR VPWR sky130_fd_sc_hd__decap_3
X_4083_ _7366_/Q _4419_/B1 _4459_/C1 _7174_/Q VGND VGND VPWR VPWR _4083_/X sky130_fd_sc_hd__a22o_2
XFILLER_55_239 VGND VGND VPWR VPWR sky130_fd_sc_hd__decap_3
XFILLER_83_537 VGND VGND VPWR VPWR sky130_fd_sc_hd__decap_3
XFILLER_70_209 VGND VGND VPWR VPWR sky130_fd_sc_hd__fill_2
XFILLER_83_559 VGND VGND VPWR VPWR sky130_fd_sc_hd__fill_1
XFILLER_24_626 VGND VGND VPWR VPWR sky130_fd_sc_hd__decap_3
XFILLER_36_464 VGND VGND VPWR VPWR sky130_fd_sc_hd__decap_3
XFILLER_63_272 VGND VGND VPWR VPWR sky130_fd_sc_hd__decap_3
XFILLER_91_570 VGND VGND VPWR VPWR sky130_fd_sc_hd__decap_3
XFILLER_51_423 VGND VGND VPWR VPWR sky130_fd_sc_hd__decap_3
Xplace272 _3892_/B1 VGND VGND VPWR VPWR _3912_/B1 sky130_fd_sc_hd__buf_2
X_4985_ _4620_/A _5032_/A _5031_/B _4630_/X VGND VGND VPWR VPWR _5003_/B sky130_fd_sc_hd__a31o_2
XFILLER_23_169 VGND VGND VPWR VPWR sky130_fd_sc_hd__decap_3
Xplace294 _3651_/Y VGND VGND VPWR VPWR _3891_/A2 sky130_fd_sc_hd__buf_2
Xplace283 _5660_/B VGND VGND VPWR VPWR _3925_/A2 sky130_fd_sc_hd__buf_2
X_6724_ _6966_/CLK _6724_/D VGND VGND VPWR VPWR _6724_/Q sky130_fd_sc_hd__dfxtp_2
XTAP_TAPCELL_ROW_34_665 VGND VPWR sky130_fd_sc_hd__tapvpwrvgnd_1
XTAP_TAPCELL_ROW_34_654 VGND VPWR sky130_fd_sc_hd__tapvpwrvgnd_1
XFILLER_32_681 VGND VGND VPWR VPWR sky130_fd_sc_hd__decap_3
XTAP_TAPCELL_ROW_62_996 VGND VPWR sky130_fd_sc_hd__tapvpwrvgnd_1
XTAP_TAPCELL_ROW_102_1476 VGND VPWR sky130_fd_sc_hd__tapvpwrvgnd_1
XFILLER_109_208 VGND VGND VPWR VPWR sky130_fd_sc_hd__decap_3
X_6655_ _6670_/A VGND VGND VPWR VPWR _6655_/Y sky130_fd_sc_hd__inv_2
X_3867_ _3629_/Y _3866_/X _5138_/S VGND VGND VPWR VPWR _3867_/X sky130_fd_sc_hd__o21a_2
X_6586_ _6587_/A VGND VGND VPWR VPWR _6586_/Y sky130_fd_sc_hd__inv_2
X_3798_ _6738_/Q _3891_/A2 _3878_/B1 _6744_/Q _3797_/X VGND VGND VPWR VPWR _3798_/X
+ sky130_fd_sc_hd__a221o_2
XFILLER_11_36 VGND VGND VPWR VPWR sky130_fd_sc_hd__decap_3
XFILLER_105_414 VGND VGND VPWR VPWR sky130_fd_sc_hd__decap_3
XFILLER_11_69 VGND VGND VPWR VPWR sky130_fd_sc_hd__decap_3
XFILLER_105_447 VGND VGND VPWR VPWR sky130_fd_sc_hd__fill_1
XFILLER_105_458 VGND VGND VPWR VPWR sky130_fd_sc_hd__decap_3
XFILLER_78_309 VGND VGND VPWR VPWR sky130_fd_sc_hd__decap_3
XFILLER_87_18 VGND VGND VPWR VPWR sky130_fd_sc_hd__decap_3
X_7207_ _7338_/CLK _7207_/D _6487_/Y VGND VGND VPWR VPWR _7207_/Q sky130_fd_sc_hd__dfrtp_2
X_4419_ _7304_/Q _4501_/S _4419_/B1 _7368_/Q _4419_/C1 VGND VGND VPWR VPWR _4419_/X
+ sky130_fd_sc_hd__a221o_2
XTAP_TAPCELL_ROW_6_324 VGND VPWR sky130_fd_sc_hd__tapvpwrvgnd_1
XFILLER_101_620 VGND VGND VPWR VPWR sky130_fd_sc_hd__decap_3
XFILLER_59_523 VGND VGND VPWR VPWR sky130_fd_sc_hd__decap_3
XFILLER_59_556 VGND VGND VPWR VPWR sky130_fd_sc_hd__decap_3
X_7138_ _7267_/CLK _7138_/D _6418_/Y VGND VGND VPWR VPWR _7138_/Q sky130_fd_sc_hd__dfrtp_2
XFILLER_100_130 VGND VGND VPWR VPWR sky130_fd_sc_hd__decap_3
XFILLER_100_141 VGND VGND VPWR VPWR sky130_fd_sc_hd__decap_3
XFILLER_46_206 VGND VGND VPWR VPWR sky130_fd_sc_hd__decap_3
XFILLER_59_589 VGND VGND VPWR VPWR sky130_fd_sc_hd__decap_3
XFILLER_74_515 VGND VGND VPWR VPWR sky130_fd_sc_hd__decap_3
XFILLER_86_353 VGND VGND VPWR VPWR sky130_fd_sc_hd__decap_3
X_7069_ clkload9/A _7069_/D _6349_/Y VGND VGND VPWR VPWR _7069_/Q sky130_fd_sc_hd__dfrtp_2
XFILLER_100_174 VGND VGND VPWR VPWR sky130_fd_sc_hd__decap_3
XFILLER_46_239 VGND VGND VPWR VPWR sky130_fd_sc_hd__decap_3
XFILLER_27_442 VGND VGND VPWR VPWR sky130_fd_sc_hd__decap_3
XFILLER_36_55 VGND VGND VPWR VPWR sky130_fd_sc_hd__decap_3
XFILLER_15_615 VGND VGND VPWR VPWR sky130_fd_sc_hd__fill_1
XFILLER_27_475 VGND VGND VPWR VPWR sky130_fd_sc_hd__fill_2
XFILLER_36_88 VGND VGND VPWR VPWR sky130_fd_sc_hd__decap_3
XTAP_TAPCELL_ROW_68_1073 VGND VPWR sky130_fd_sc_hd__tapvpwrvgnd_1
XTAP_TAPCELL_ROW_68_1062 VGND VPWR sky130_fd_sc_hd__tapvpwrvgnd_1
XFILLER_27_497 VGND VGND VPWR VPWR sky130_fd_sc_hd__fill_2
XFILLER_36_99 VGND VGND VPWR VPWR sky130_fd_sc_hd__decap_3
XFILLER_42_434 VGND VGND VPWR VPWR sky130_fd_sc_hd__decap_3
XFILLER_54_283 VGND VGND VPWR VPWR sky130_fd_sc_hd__decap_3
XFILLER_82_592 VGND VGND VPWR VPWR sky130_fd_sc_hd__fill_2
XFILLER_14_147 VGND VGND VPWR VPWR sky130_fd_sc_hd__decap_3
XFILLER_52_21 VGND VGND VPWR VPWR sky130_fd_sc_hd__decap_3
XFILLER_52_32 VGND VGND VPWR VPWR sky130_fd_sc_hd__decap_3
XFILLER_52_54 VGND VGND VPWR VPWR sky130_fd_sc_hd__fill_1
XFILLER_52_76 VGND VGND VPWR VPWR sky130_fd_sc_hd__decap_3
XFILLER_10_353 VGND VGND VPWR VPWR sky130_fd_sc_hd__decap_3
XFILLER_6_324 VGND VGND VPWR VPWR sky130_fd_sc_hd__fill_2
XFILLER_6_368 VGND VGND VPWR VPWR sky130_fd_sc_hd__fill_2
XFILLER_104_491 VGND VGND VPWR VPWR sky130_fd_sc_hd__decap_3
XFILLER_77_51 VGND VGND VPWR VPWR sky130_fd_sc_hd__decap_3
XFILLER_89_180 VGND VGND VPWR VPWR sky130_fd_sc_hd__decap_3
XFILLER_89_191 VGND VGND VPWR VPWR sky130_fd_sc_hd__decap_3
XFILLER_77_364 VGND VGND VPWR VPWR sky130_fd_sc_hd__decap_3
XFILLER_77_95 VGND VGND VPWR VPWR sky130_fd_sc_hd__decap_3
XFILLER_37_217 VGND VGND VPWR VPWR sky130_fd_sc_hd__fill_1
XFILLER_92_312 VGND VGND VPWR VPWR sky130_fd_sc_hd__decap_3
XFILLER_18_486 VGND VGND VPWR VPWR sky130_fd_sc_hd__decap_3
XFILLER_45_261 VGND VGND VPWR VPWR sky130_fd_sc_hd__decap_3
XFILLER_80_518 VGND VGND VPWR VPWR sky130_fd_sc_hd__decap_3
XFILLER_33_423 VGND VGND VPWR VPWR sky130_fd_sc_hd__decap_3
XFILLER_93_94 VGND VGND VPWR VPWR sky130_fd_sc_hd__decap_3
XFILLER_33_456 VGND VGND VPWR VPWR sky130_fd_sc_hd__decap_3
XFILLER_60_253 VGND VGND VPWR VPWR sky130_fd_sc_hd__fill_1
X_4770_ _3833_/S _3692_/X _5663_/A _3509_/B VGND VGND VPWR VPWR _4770_/X sky130_fd_sc_hd__a211o_2
XTAP_TAPCELL_ROW_31_624 VGND VPWR sky130_fd_sc_hd__tapvpwrvgnd_1
X_3721_ _6863_/Q _3889_/A2 _3889_/B1 _6855_/Q _3720_/X VGND VGND VPWR VPWR _3721_/X
+ sky130_fd_sc_hd__a221o_2
X_6440_ _6532_/A VGND VGND VPWR VPWR _6440_/Y sky130_fd_sc_hd__inv_2
XFILLER_9_184 VGND VGND VPWR VPWR sky130_fd_sc_hd__decap_3
X_6371_ _6567_/A VGND VGND VPWR VPWR _6371_/Y sky130_fd_sc_hd__inv_2
X_3583_ _3583_/A _3583_/B _3583_/C VGND VGND VPWR VPWR _3583_/X sky130_fd_sc_hd__or3_4
XTAP_TAPCELL_ROW_11_381 VGND VPWR sky130_fd_sc_hd__tapvpwrvgnd_1
XFILLER_114_200 VGND VGND VPWR VPWR sky130_fd_sc_hd__decap_3
XFILLER_114_233 VGND VGND VPWR VPWR sky130_fd_sc_hd__decap_3
XFILLER_88_607 VGND VGND VPWR VPWR sky130_fd_sc_hd__fill_1
XFILLER_102_406 VGND VGND VPWR VPWR sky130_fd_sc_hd__decap_3
XFILLER_114_277 VGND VGND VPWR VPWR sky130_fd_sc_hd__decap_3
XFILLER_88_629 VGND VGND VPWR VPWR sky130_fd_sc_hd__decap_3
X_5253_ _5253_/A0 _4913_/X _5262_/S VGND VGND VPWR VPWR _7203_/D sky130_fd_sc_hd__mux2_2
XFILLER_68_331 VGND VGND VPWR VPWR sky130_fd_sc_hd__decap_3
XFILLER_87_128 VGND VGND VPWR VPWR sky130_fd_sc_hd__decap_3
X_5184_ _5184_/A _5194_/B VGND VGND VPWR VPWR _7236_/D sky130_fd_sc_hd__and2_2
X_4204_ _4936_/A _4201_/X _4203_/X VGND VGND VPWR VPWR _4204_/Y sky130_fd_sc_hd__o21bai_2
XFILLER_3_81 VGND VGND VPWR VPWR sky130_fd_sc_hd__decap_3
XFILLER_95_150 VGND VGND VPWR VPWR sky130_fd_sc_hd__decap_3
XFILLER_96_662 VGND VGND VPWR VPWR sky130_fd_sc_hd__decap_3
X_4135_ _7107_/Q _4351_/A2 _4195_/A2 _7139_/Q VGND VGND VPWR VPWR _4135_/X sky130_fd_sc_hd__a22o_2
XFILLER_113_27 VGND VGND VPWR VPWR sky130_fd_sc_hd__decap_3
XFILLER_28_206 VGND VGND VPWR VPWR sky130_fd_sc_hd__decap_3
XFILLER_68_386 VGND VGND VPWR VPWR sky130_fd_sc_hd__decap_3
XFILLER_95_172 VGND VGND VPWR VPWR sky130_fd_sc_hd__fill_2
XTAP_TAPCELL_ROW_39_724 VGND VPWR sky130_fd_sc_hd__tapvpwrvgnd_1
X_4066_ _4062_/X _4065_/X _4425_/A VGND VGND VPWR VPWR _4082_/A sky130_fd_sc_hd__o21a_2
XTAP_TAPCELL_ROW_104_1505 VGND VPWR sky130_fd_sc_hd__tapvpwrvgnd_1
XFILLER_64_581 VGND VGND VPWR VPWR sky130_fd_sc_hd__decap_3
XTAP_TAPCELL_ROW_19_481 VGND VPWR sky130_fd_sc_hd__tapvpwrvgnd_1
X_4968_ _4968_/A _4967_/B VGND VGND VPWR VPWR _4968_/Y sky130_fd_sc_hd__nor2b_2
XFILLER_22_24 VGND VGND VPWR VPWR sky130_fd_sc_hd__decap_3
X_6707_ _7406_/CLK _6707_/D VGND VGND VPWR VPWR _6707_/Q sky130_fd_sc_hd__dfxtp_2
X_4899_ _4836_/S _6998_/D _5656_/B _4898_/X VGND VGND VPWR VPWR _4899_/X sky130_fd_sc_hd__o22a_2
X_3919_ _3923_/A1 _3918_/X _5104_/A VGND VGND VPWR VPWR _3919_/X sky130_fd_sc_hd__a21o_2
X_6638_ _6638_/A VGND VGND VPWR VPWR _6638_/Y sky130_fd_sc_hd__inv_2
XFILLER_22_68 VGND VGND VPWR VPWR sky130_fd_sc_hd__decap_3
X_6569_ _6638_/A VGND VGND VPWR VPWR _6569_/Y sky130_fd_sc_hd__inv_2
XTAP_TAPCELL_ROW_115_1634 VGND VPWR sky130_fd_sc_hd__tapvpwrvgnd_1
XFILLER_105_222 VGND VGND VPWR VPWR sky130_fd_sc_hd__fill_2
XFILLER_105_255 VGND VGND VPWR VPWR sky130_fd_sc_hd__decap_3
XFILLER_105_277 VGND VGND VPWR VPWR sky130_fd_sc_hd__decap_3
XFILLER_78_117 VGND VGND VPWR VPWR sky130_fd_sc_hd__fill_1
Xoutput470 _5657_/C VGND VGND VPWR VPWR alu_result_out[18] sky130_fd_sc_hd__clkdlybuf4s25_1
XFILLER_59_320 VGND VGND VPWR VPWR sky130_fd_sc_hd__fill_2
XFILLER_59_331 VGND VGND VPWR VPWR sky130_fd_sc_hd__decap_3
Xoutput492 _5658_/C VGND VGND VPWR VPWR alu_result_out[9] sky130_fd_sc_hd__clkdlybuf4s25_1
Xoutput481 _5663_/A VGND VGND VPWR VPWR alu_result_out[28] sky130_fd_sc_hd__clkdlybuf4s25_1
XFILLER_47_21 VGND VGND VPWR VPWR sky130_fd_sc_hd__decap_3
XFILLER_86_150 VGND VGND VPWR VPWR sky130_fd_sc_hd__decap_3
XFILLER_87_673 VGND VGND VPWR VPWR sky130_fd_sc_hd__decap_3
XFILLER_101_483 VGND VGND VPWR VPWR sky130_fd_sc_hd__decap_3
XFILLER_19_228 VGND VGND VPWR VPWR sky130_fd_sc_hd__decap_3
XFILLER_59_375 VGND VGND VPWR VPWR sky130_fd_sc_hd__decap_3
XFILLER_47_559 VGND VGND VPWR VPWR sky130_fd_sc_hd__fill_1
XFILLER_47_87 VGND VGND VPWR VPWR sky130_fd_sc_hd__decap_3
XFILLER_103_60 VGND VGND VPWR VPWR sky130_fd_sc_hd__decap_3
XFILLER_34_209 VGND VGND VPWR VPWR sky130_fd_sc_hd__decap_3
XFILLER_55_570 VGND VGND VPWR VPWR sky130_fd_sc_hd__fill_2
XFILLER_74_389 VGND VGND VPWR VPWR sky130_fd_sc_hd__decap_3
XFILLER_103_93 VGND VGND VPWR VPWR sky130_fd_sc_hd__decap_3
XFILLER_27_272 VGND VGND VPWR VPWR sky130_fd_sc_hd__decap_3
XFILLER_42_242 VGND VGND VPWR VPWR sky130_fd_sc_hd__decap_3
XFILLER_42_253 VGND VGND VPWR VPWR sky130_fd_sc_hd__decap_3
XFILLER_63_53 VGND VGND VPWR VPWR sky130_fd_sc_hd__decap_3
XFILLER_70_540 VGND VGND VPWR VPWR sky130_fd_sc_hd__decap_3
XPHY_EDGE_ROW_69_Right_69 VGND VGND VPWR VPWR sky130_fd_sc_hd__decap_3
XFILLER_15_489 VGND VGND VPWR VPWR sky130_fd_sc_hd__fill_2
XFILLER_30_415 VGND VGND VPWR VPWR sky130_fd_sc_hd__decap_3
XFILLER_42_286 VGND VGND VPWR VPWR sky130_fd_sc_hd__decap_3
XFILLER_42_297 VGND VGND VPWR VPWR sky130_fd_sc_hd__decap_3
XFILLER_11_651 VGND VGND VPWR VPWR sky130_fd_sc_hd__decap_3
XFILLER_30_459 VGND VGND VPWR VPWR sky130_fd_sc_hd__fill_2
XFILLER_8_26 VGND VGND VPWR VPWR sky130_fd_sc_hd__fill_2
XFILLER_11_673 VGND VGND VPWR VPWR sky130_fd_sc_hd__fill_2
XFILLER_8_59 VGND VGND VPWR VPWR sky130_fd_sc_hd__decap_3
XFILLER_6_121 VGND VGND VPWR VPWR sky130_fd_sc_hd__decap_3
XFILLER_7_644 VGND VGND VPWR VPWR sky130_fd_sc_hd__decap_3
XFILLER_109_561 VGND VGND VPWR VPWR sky130_fd_sc_hd__decap_3
XFILLER_7_688 VGND VGND VPWR VPWR sky130_fd_sc_hd__decap_3
XPHY_EDGE_ROW_78_Right_78 VGND VGND VPWR VPWR sky130_fd_sc_hd__decap_3
XFILLER_88_61 VGND VGND VPWR VPWR sky130_fd_sc_hd__decap_3
XTAP_TAPCELL_ROW_90_1328 VGND VPWR sky130_fd_sc_hd__tapvpwrvgnd_1
XFILLER_2_371 VGND VGND VPWR VPWR sky130_fd_sc_hd__decap_3
XFILLER_33_6 VGND VGND VPWR VPWR sky130_fd_sc_hd__decap_3
XFILLER_69_128 VGND VGND VPWR VPWR sky130_fd_sc_hd__decap_3
XFILLER_88_94 VGND VGND VPWR VPWR sky130_fd_sc_hd__decap_3
XFILLER_78_651 VGND VGND VPWR VPWR sky130_fd_sc_hd__decap_3
XFILLER_78_673 VGND VGND VPWR VPWR sky130_fd_sc_hd__decap_3
XFILLER_65_323 VGND VGND VPWR VPWR sky130_fd_sc_hd__decap_3
XFILLER_92_120 VGND VGND VPWR VPWR sky130_fd_sc_hd__decap_3
XFILLER_93_665 VGND VGND VPWR VPWR sky130_fd_sc_hd__decap_3
XFILLER_46_570 VGND VGND VPWR VPWR sky130_fd_sc_hd__fill_2
XFILLER_93_676 VGND VGND VPWR VPWR sky130_fd_sc_hd__decap_3
XFILLER_46_581 VGND VGND VPWR VPWR sky130_fd_sc_hd__decap_3
XFILLER_80_326 VGND VGND VPWR VPWR sky130_fd_sc_hd__decap_3
XFILLER_92_197 VGND VGND VPWR VPWR sky130_fd_sc_hd__decap_3
XPHY_EDGE_ROW_87_Right_87 VGND VGND VPWR VPWR sky130_fd_sc_hd__decap_3
XFILLER_33_253 VGND VGND VPWR VPWR sky130_fd_sc_hd__decap_3
XTAP_TAPCELL_ROW_16_440 VGND VPWR sky130_fd_sc_hd__tapvpwrvgnd_1
XFILLER_21_437 VGND VGND VPWR VPWR sky130_fd_sc_hd__fill_2
XFILLER_33_275 VGND VGND VPWR VPWR sky130_fd_sc_hd__decap_3
X_4822_ _4836_/S _7002_/D _5663_/B _4821_/X VGND VGND VPWR VPWR _4822_/X sky130_fd_sc_hd__o22a_2
XTAP_TAPCELL_ROW_44_782 VGND VPWR sky130_fd_sc_hd__tapvpwrvgnd_1
X_4753_ _4753_/A0 _4752_/X _4772_/S VGND VGND VPWR VPWR _7276_/D sky130_fd_sc_hd__mux2_2
X_3704_ _6712_/Q _3767_/A2 _3826_/B1 _6890_/Q _3703_/X VGND VGND VPWR VPWR _3704_/X
+ sky130_fd_sc_hd__a221o_2
X_6423_ _6617_/A VGND VGND VPWR VPWR _6423_/Y sky130_fd_sc_hd__inv_2
X_4684_ _6996_/Q _4668_/X _4943_/A _4683_/X VGND VGND VPWR VPWR _4684_/X sky130_fd_sc_hd__a31o_2
X_3635_ _3635_/A _3635_/B _3547_/A VGND VGND VPWR VPWR _3635_/X sky130_fd_sc_hd__or3b_2
XPHY_EDGE_ROW_96_Right_96 VGND VGND VPWR VPWR sky130_fd_sc_hd__decap_3
XFILLER_108_27 VGND VGND VPWR VPWR sky130_fd_sc_hd__fill_1
XFILLER_108_38 VGND VGND VPWR VPWR sky130_fd_sc_hd__decap_3
XFILLER_115_542 VGND VGND VPWR VPWR sky130_fd_sc_hd__decap_3
X_6354_ _6388_/A VGND VGND VPWR VPWR _6354_/Y sky130_fd_sc_hd__inv_2
X_3566_ _7189_/Q _3973_/S _4338_/B1 _7381_/Q VGND VGND VPWR VPWR _3566_/X sky130_fd_sc_hd__a22o_2
XFILLER_115_564 VGND VGND VPWR VPWR sky130_fd_sc_hd__decap_3
X_6285_ _6285_/A VGND VGND VPWR VPWR _6285_/Y sky130_fd_sc_hd__inv_2
X_3497_ _7151_/Q _4352_/B1 _3493_/X _3496_/X VGND VGND VPWR VPWR _3497_/X sky130_fd_sc_hd__a211o_2
XFILLER_115_597 VGND VGND VPWR VPWR sky130_fd_sc_hd__decap_3
X_5236_ _5236_/A0 _4752_/X _5245_/S VGND VGND VPWR VPWR _7212_/D sky130_fd_sc_hd__mux2_2
XFILLER_102_247 VGND VGND VPWR VPWR sky130_fd_sc_hd__fill_2
XTAP_TAPCELL_ROW_110_1575 VGND VPWR sky130_fd_sc_hd__tapvpwrvgnd_1
XFILLER_56_301 VGND VGND VPWR VPWR sky130_fd_sc_hd__decap_3
XFILLER_56_312 VGND VGND VPWR VPWR sky130_fd_sc_hd__decap_3
XFILLER_68_150 VGND VGND VPWR VPWR sky130_fd_sc_hd__decap_3
XFILLER_69_673 VGND VGND VPWR VPWR sky130_fd_sc_hd__decap_3
XFILLER_84_610 VGND VGND VPWR VPWR sky130_fd_sc_hd__decap_3
X_5167_ _5167_/A _5182_/B VGND VGND VPWR VPWR _7244_/D sky130_fd_sc_hd__and2_2
XPHY_EDGE_ROW_3_Left_120 VGND VGND VPWR VPWR sky130_fd_sc_hd__decap_3
XFILLER_29_559 VGND VGND VPWR VPWR sky130_fd_sc_hd__fill_1
XFILLER_56_334 VGND VGND VPWR VPWR sky130_fd_sc_hd__decap_3
XFILLER_68_183 VGND VGND VPWR VPWR sky130_fd_sc_hd__decap_3
XFILLER_83_131 VGND VGND VPWR VPWR sky130_fd_sc_hd__decap_3
XFILLER_96_492 VGND VGND VPWR VPWR sky130_fd_sc_hd__decap_3
X_5098_ _5098_/A _5098_/B VGND VGND VPWR VPWR _6985_/D sky130_fd_sc_hd__nor2_2
X_4118_ _7021_/Q _4408_/A2 _4394_/B _7364_/Q VGND VGND VPWR VPWR _4118_/X sky130_fd_sc_hd__a22o_2
XFILLER_17_24 VGND VGND VPWR VPWR sky130_fd_sc_hd__decap_3
XFILLER_44_507 VGND VGND VPWR VPWR sky130_fd_sc_hd__decap_3
XFILLER_83_175 VGND VGND VPWR VPWR sky130_fd_sc_hd__fill_1
XFILLER_84_676 VGND VGND VPWR VPWR sky130_fd_sc_hd__decap_3
X_4049_ _7213_/Q _3947_/S _4772_/S _7309_/Q _4048_/X VGND VGND VPWR VPWR _4049_/X
+ sky130_fd_sc_hd__a221o_2
XFILLER_17_57 VGND VGND VPWR VPWR sky130_fd_sc_hd__fill_1
XFILLER_83_197 VGND VGND VPWR VPWR sky130_fd_sc_hd__decap_3
XFILLER_24_231 VGND VGND VPWR VPWR sky130_fd_sc_hd__decap_3
XFILLER_24_253 VGND VGND VPWR VPWR sky130_fd_sc_hd__decap_3
XTAP_TAPCELL_ROW_65_1032 VGND VPWR sky130_fd_sc_hd__tapvpwrvgnd_1
XFILLER_33_12 VGND VGND VPWR VPWR sky130_fd_sc_hd__fill_2
XFILLER_33_23 VGND VGND VPWR VPWR sky130_fd_sc_hd__decap_3
XFILLER_52_595 VGND VGND VPWR VPWR sky130_fd_sc_hd__decap_3
XFILLER_8_408 VGND VGND VPWR VPWR sky130_fd_sc_hd__decap_3
XPHY_EDGE_ROW_49_Left_166 VGND VGND VPWR VPWR sky130_fd_sc_hd__decap_3
XFILLER_3_102 VGND VGND VPWR VPWR sky130_fd_sc_hd__decap_3
XFILLER_106_542 VGND VGND VPWR VPWR sky130_fd_sc_hd__decap_3
XFILLER_3_113 VGND VGND VPWR VPWR sky130_fd_sc_hd__decap_3
XFILLER_106_564 VGND VGND VPWR VPWR sky130_fd_sc_hd__decap_3
XFILLER_3_146 VGND VGND VPWR VPWR sky130_fd_sc_hd__decap_3
XFILLER_4_669 VGND VGND VPWR VPWR sky130_fd_sc_hd__decap_3
XTAP_TAPCELL_ROW_76_1161 VGND VPWR sky130_fd_sc_hd__tapvpwrvgnd_1
XFILLER_79_426 VGND VGND VPWR VPWR sky130_fd_sc_hd__decap_3
XFILLER_58_53 VGND VGND VPWR VPWR sky130_fd_sc_hd__decap_3
XFILLER_47_301 VGND VGND VPWR VPWR sky130_fd_sc_hd__decap_3
XFILLER_58_75 VGND VGND VPWR VPWR sky130_fd_sc_hd__decap_3
XFILLER_58_97 VGND VGND VPWR VPWR sky130_fd_sc_hd__decap_3
XFILLER_59_161 VGND VGND VPWR VPWR sky130_fd_sc_hd__decap_3
XFILLER_59_172 VGND VGND VPWR VPWR sky130_fd_sc_hd__decap_3
XFILLER_75_610 VGND VGND VPWR VPWR sky130_fd_sc_hd__fill_1
XPHY_EDGE_ROW_58_Left_175 VGND VGND VPWR VPWR sky130_fd_sc_hd__decap_3
XFILLER_74_120 VGND VGND VPWR VPWR sky130_fd_sc_hd__fill_1
XFILLER_74_131 VGND VGND VPWR VPWR sky130_fd_sc_hd__fill_1
XFILLER_75_665 VGND VGND VPWR VPWR sky130_fd_sc_hd__decap_3
XFILLER_74_41 VGND VGND VPWR VPWR sky130_fd_sc_hd__decap_3
XFILLER_75_676 VGND VGND VPWR VPWR sky130_fd_sc_hd__decap_3
XFILLER_15_220 VGND VGND VPWR VPWR sky130_fd_sc_hd__decap_3
XFILLER_74_197 VGND VGND VPWR VPWR sky130_fd_sc_hd__decap_3
XFILLER_74_85 VGND VGND VPWR VPWR sky130_fd_sc_hd__decap_3
XFILLER_90_679 VGND VGND VPWR VPWR sky130_fd_sc_hd__decap_3
XTAP_TAPCELL_ROW_87_1290 VGND VPWR sky130_fd_sc_hd__tapvpwrvgnd_1
XFILLER_15_264 VGND VGND VPWR VPWR sky130_fd_sc_hd__decap_3
XFILLER_30_212 VGND VGND VPWR VPWR sky130_fd_sc_hd__decap_3
XFILLER_70_381 VGND VGND VPWR VPWR sky130_fd_sc_hd__decap_3
XFILLER_90_73 VGND VGND VPWR VPWR sky130_fd_sc_hd__decap_3
XTAP_TAPCELL_ROW_41_741 VGND VPWR sky130_fd_sc_hd__tapvpwrvgnd_1
XTAP_TAPCELL_ROW_13_410 VGND VPWR sky130_fd_sc_hd__tapvpwrvgnd_1
XPHY_EDGE_ROW_67_Left_184 VGND VGND VPWR VPWR sky130_fd_sc_hd__decap_3
XFILLER_30_256 VGND VGND VPWR VPWR sky130_fd_sc_hd__fill_1
XFILLER_30_278 VGND VGND VPWR VPWR sky130_fd_sc_hd__decap_3
XFILLER_116_328 VGND VGND VPWR VPWR sky130_fd_sc_hd__decap_3
XFILLER_7_452 VGND VGND VPWR VPWR sky130_fd_sc_hd__decap_3
XFILLER_109_391 VGND VGND VPWR VPWR sky130_fd_sc_hd__fill_1
X_3420_ _3420_/A _5642_/B VGND VGND VPWR VPWR _3442_/B sky130_fd_sc_hd__or2_2
XFILLER_99_60 VGND VGND VPWR VPWR sky130_fd_sc_hd__decap_3
X_3351_ _5130_/A _3350_/Y _3340_/B VGND VGND VPWR VPWR _5642_/B sky130_fd_sc_hd__o21a_2
XFILLER_99_93 VGND VGND VPWR VPWR sky130_fd_sc_hd__decap_3
XFILLER_31_3 VGND VGND VPWR VPWR sky130_fd_sc_hd__fill_1
XFILLER_112_545 VGND VGND VPWR VPWR sky130_fd_sc_hd__decap_3
XFILLER_97_267 VGND VGND VPWR VPWR sky130_fd_sc_hd__decap_3
XPHY_EDGE_ROW_76_Left_193 VGND VGND VPWR VPWR sky130_fd_sc_hd__decap_3
XFILLER_112_589 VGND VGND VPWR VPWR sky130_fd_sc_hd__decap_3
XFILLER_38_301 VGND VGND VPWR VPWR sky130_fd_sc_hd__decap_3
XFILLER_38_312 VGND VGND VPWR VPWR sky130_fd_sc_hd__decap_3
XFILLER_66_610 VGND VGND VPWR VPWR sky130_fd_sc_hd__decap_3
Xhold1108 _4495_/X VGND VGND VPWR VPWR _7332_/D sky130_fd_sc_hd__dlygate4sd3_1
Xhold1119 _4486_/X VGND VGND VPWR VPWR _7336_/D sky130_fd_sc_hd__dlygate4sd3_1
X_5021_ _5114_/A _4372_/A _5018_/A _5101_/A VGND VGND VPWR VPWR _5021_/X sky130_fd_sc_hd__o2bb2a_2
XFILLER_66_654 VGND VGND VPWR VPWR sky130_fd_sc_hd__decap_3
XFILLER_78_492 VGND VGND VPWR VPWR sky130_fd_sc_hd__decap_3
XTAP_TAPCELL_ROW_49_841 VGND VPWR sky130_fd_sc_hd__tapvpwrvgnd_1
XFILLER_38_389 VGND VGND VPWR VPWR sky130_fd_sc_hd__decap_3
XFILLER_65_153 VGND VGND VPWR VPWR sky130_fd_sc_hd__decap_3
XFILLER_66_687 VGND VGND VPWR VPWR sky130_fd_sc_hd__decap_3
XFILLER_81_602 VGND VGND VPWR VPWR sky130_fd_sc_hd__decap_3
XFILLER_93_473 VGND VGND VPWR VPWR sky130_fd_sc_hd__decap_3
XFILLER_0_71 VGND VGND VPWR VPWR sky130_fd_sc_hd__decap_3
XFILLER_53_337 VGND VGND VPWR VPWR sky130_fd_sc_hd__decap_3
XFILLER_65_175 VGND VGND VPWR VPWR sky130_fd_sc_hd__decap_3
X_6972_ _6972_/CLK _6972_/D VGND VGND VPWR VPWR _6972_/Q sky130_fd_sc_hd__dfxtp_2
XFILLER_53_359 VGND VGND VPWR VPWR sky130_fd_sc_hd__decap_3
XFILLER_80_156 VGND VGND VPWR VPWR sky130_fd_sc_hd__fill_1
XFILLER_81_679 VGND VGND VPWR VPWR sky130_fd_sc_hd__decap_3
XFILLER_61_381 VGND VGND VPWR VPWR sky130_fd_sc_hd__decap_3
XFILLER_80_189 VGND VGND VPWR VPWR sky130_fd_sc_hd__decap_3
XFILLER_21_223 VGND VGND VPWR VPWR sky130_fd_sc_hd__fill_1
XFILLER_21_234 VGND VGND VPWR VPWR sky130_fd_sc_hd__decap_3
X_4805_ _4997_/A1 _7003_/D _4804_/X VGND VGND VPWR VPWR _4805_/X sky130_fd_sc_hd__a21bo_2
XFILLER_107_328 VGND VGND VPWR VPWR sky130_fd_sc_hd__decap_3
X_4667_ _6998_/Q _4667_/B VGND VGND VPWR VPWR _4896_/A sky130_fd_sc_hd__xnor2_2
XFILLER_102_9 VGND VGND VPWR VPWR sky130_fd_sc_hd__decap_3
XFILLER_79_19 VGND VGND VPWR VPWR sky130_fd_sc_hd__decap_3
X_7386_ _7386_/CLK _7386_/D _6666_/Y VGND VGND VPWR VPWR _7386_/Q sky130_fd_sc_hd__dfrtp_2
Xhold920 _6699_/Q VGND VGND VPWR VPWR hold920/X sky130_fd_sc_hd__dlygate4sd3_1
Xhold931 _7020_/Q VGND VGND VPWR VPWR _5615_/A sky130_fd_sc_hd__dlygate4sd3_1
X_6406_ _6532_/A VGND VGND VPWR VPWR _6406_/Y sky130_fd_sc_hd__inv_2
X_3618_ _5118_/C _4938_/A _3618_/C VGND VGND VPWR VPWR _3618_/X sky130_fd_sc_hd__and3_2
XFILLER_1_606 VGND VGND VPWR VPWR sky130_fd_sc_hd__decap_3
XFILLER_1_617 VGND VGND VPWR VPWR sky130_fd_sc_hd__decap_3
Xhold964 _7315_/Q VGND VGND VPWR VPWR _4528_/A sky130_fd_sc_hd__dlygate4sd3_1
Xhold953 _7053_/Q VGND VGND VPWR VPWR hold953/X sky130_fd_sc_hd__dlygate4sd3_1
Xhold942 _7018_/Q VGND VGND VPWR VPWR _5619_/A sky130_fd_sc_hd__dlygate4sd3_1
X_6337_ _6347_/A VGND VGND VPWR VPWR _6337_/Y sky130_fd_sc_hd__inv_2
XFILLER_0_116 VGND VGND VPWR VPWR sky130_fd_sc_hd__fill_2
XFILLER_88_212 VGND VGND VPWR VPWR sky130_fd_sc_hd__decap_3
Xhold997 _7231_/Q VGND VGND VPWR VPWR _5194_/A sky130_fd_sc_hd__dlygate4sd3_1
Xhold986 _7034_/Q VGND VGND VPWR VPWR _5587_/A sky130_fd_sc_hd__dlygate4sd3_1
Xhold975 _7389_/Q VGND VGND VPWR VPWR hold975/X sky130_fd_sc_hd__dlygate4sd3_1
XFILLER_0_138 VGND VGND VPWR VPWR sky130_fd_sc_hd__fill_2
XFILLER_103_567 VGND VGND VPWR VPWR sky130_fd_sc_hd__decap_3
XFILLER_76_407 VGND VGND VPWR VPWR sky130_fd_sc_hd__fill_1
XFILLER_95_18 VGND VGND VPWR VPWR sky130_fd_sc_hd__decap_3
X_6268_ _6366_/A VGND VGND VPWR VPWR _6268_/Y sky130_fd_sc_hd__inv_2
XFILLER_76_429 VGND VGND VPWR VPWR sky130_fd_sc_hd__decap_3
X_5219_ _5219_/A _5225_/B VGND VGND VPWR VPWR _7219_/D sky130_fd_sc_hd__and2_2
XFILLER_57_632 VGND VGND VPWR VPWR sky130_fd_sc_hd__decap_3
XFILLER_28_78 VGND VGND VPWR VPWR sky130_fd_sc_hd__decap_3
XFILLER_57_665 VGND VGND VPWR VPWR sky130_fd_sc_hd__decap_3
XFILLER_57_676 VGND VGND VPWR VPWR sky130_fd_sc_hd__decap_3
XFILLER_72_613 VGND VGND VPWR VPWR sky130_fd_sc_hd__decap_3
XFILLER_84_451 VGND VGND VPWR VPWR sky130_fd_sc_hd__decap_3
XFILLER_29_389 VGND VGND VPWR VPWR sky130_fd_sc_hd__decap_3
XFILLER_44_315 VGND VGND VPWR VPWR sky130_fd_sc_hd__decap_3
XFILLER_44_348 VGND VGND VPWR VPWR sky130_fd_sc_hd__decap_3
XFILLER_56_175 VGND VGND VPWR VPWR sky130_fd_sc_hd__decap_3
XFILLER_56_197 VGND VGND VPWR VPWR sky130_fd_sc_hd__fill_2
XFILLER_71_101 VGND VGND VPWR VPWR sky130_fd_sc_hd__decap_3
XFILLER_71_123 VGND VGND VPWR VPWR sky130_fd_sc_hd__decap_3
XFILLER_71_167 VGND VGND VPWR VPWR sky130_fd_sc_hd__fill_1
XFILLER_12_212 VGND VGND VPWR VPWR sky130_fd_sc_hd__decap_3
XFILLER_44_77 VGND VGND VPWR VPWR sky130_fd_sc_hd__decap_3
XTAP_TAPCELL_ROW_27_579 VGND VPWR sky130_fd_sc_hd__tapvpwrvgnd_1
XFILLER_44_88 VGND VGND VPWR VPWR sky130_fd_sc_hd__decap_3
XFILLER_80_690 VGND VGND VPWR VPWR sky130_fd_sc_hd__fill_2
XFILLER_100_50 VGND VGND VPWR VPWR sky130_fd_sc_hd__decap_3
XFILLER_8_205 VGND VGND VPWR VPWR sky130_fd_sc_hd__decap_3
XFILLER_100_94 VGND VGND VPWR VPWR sky130_fd_sc_hd__decap_3
XFILLER_12_289 VGND VGND VPWR VPWR sky130_fd_sc_hd__decap_3
XFILLER_60_32 VGND VGND VPWR VPWR sky130_fd_sc_hd__decap_3
XFILLER_60_54 VGND VGND VPWR VPWR sky130_fd_sc_hd__decap_3
XFILLER_4_411 VGND VGND VPWR VPWR sky130_fd_sc_hd__decap_3
XFILLER_5_27 VGND VGND VPWR VPWR sky130_fd_sc_hd__decap_3
XFILLER_106_350 VGND VGND VPWR VPWR sky130_fd_sc_hd__decap_3
XFILLER_109_81 VGND VGND VPWR VPWR sky130_fd_sc_hd__decap_3
XFILLER_4_455 VGND VGND VPWR VPWR sky130_fd_sc_hd__decap_3
XFILLER_4_477 VGND VGND VPWR VPWR sky130_fd_sc_hd__decap_3
XFILLER_69_30 VGND VGND VPWR VPWR sky130_fd_sc_hd__decap_3
XFILLER_48_621 VGND VGND VPWR VPWR sky130_fd_sc_hd__decap_3
XFILLER_48_654 VGND VGND VPWR VPWR sky130_fd_sc_hd__decap_3
XFILLER_94_259 VGND VGND VPWR VPWR sky130_fd_sc_hd__decap_3
XFILLER_35_304 VGND VGND VPWR VPWR sky130_fd_sc_hd__decap_3
XFILLER_75_473 VGND VGND VPWR VPWR sky130_fd_sc_hd__decap_3
XFILLER_85_73 VGND VGND VPWR VPWR sky130_fd_sc_hd__decap_3
XFILLER_85_84 VGND VGND VPWR VPWR sky130_fd_sc_hd__decap_3
XTAP_TAPCELL_ROW_46_800 VGND VPWR sky130_fd_sc_hd__tapvpwrvgnd_1
XFILLER_35_337 VGND VGND VPWR VPWR sky130_fd_sc_hd__decap_3
XFILLER_47_175 VGND VGND VPWR VPWR sky130_fd_sc_hd__decap_3
XFILLER_47_197 VGND VGND VPWR VPWR sky130_fd_sc_hd__decap_3
XFILLER_63_635 VGND VGND VPWR VPWR sky130_fd_sc_hd__decap_3
XFILLER_90_421 VGND VGND VPWR VPWR sky130_fd_sc_hd__decap_3
XFILLER_63_668 VGND VGND VPWR VPWR sky130_fd_sc_hd__decap_3
XFILLER_63_679 VGND VGND VPWR VPWR sky130_fd_sc_hd__decap_3
XFILLER_90_454 VGND VGND VPWR VPWR sky130_fd_sc_hd__fill_1
XFILLER_16_562 VGND VGND VPWR VPWR sky130_fd_sc_hd__decap_3
XFILLER_62_178 VGND VGND VPWR VPWR sky130_fd_sc_hd__decap_3
XFILLER_31_532 VGND VGND VPWR VPWR sky130_fd_sc_hd__decap_3
XFILLER_79_3 VGND VGND VPWR VPWR sky130_fd_sc_hd__decap_3
X_5570_ hold972/X _5015_/A _4929_/Y VGND VGND VPWR VPWR _7047_/D sky130_fd_sc_hd__o21a_2
XFILLER_116_103 VGND VGND VPWR VPWR sky130_fd_sc_hd__decap_3
X_7240_ _7368_/CLK _7240_/D _6520_/Y VGND VGND VPWR VPWR _7240_/Q sky130_fd_sc_hd__dfrtp_2
X_4452_ _4452_/A _4765_/B VGND VGND VPWR VPWR _4453_/A sky130_fd_sc_hd__or2_2
XFILLER_104_309 VGND VGND VPWR VPWR sky130_fd_sc_hd__fill_2
XFILLER_116_147 VGND VGND VPWR VPWR sky130_fd_sc_hd__decap_3
XFILLER_116_158 VGND VGND VPWR VPWR sky130_fd_sc_hd__decap_3
XFILLER_116_169 VGND VGND VPWR VPWR sky130_fd_sc_hd__decap_3
X_3403_ _3403_/A _4467_/B VGND VGND VPWR VPWR _4667_/B sky130_fd_sc_hd__or2_4
XPHY_EDGE_ROW_84_Left_201 VGND VGND VPWR VPWR sky130_fd_sc_hd__decap_3
X_7171_ _7363_/CLK _7171_/D _6451_/Y VGND VGND VPWR VPWR _7171_/Q sky130_fd_sc_hd__dfrtp_2
X_4383_ _4920_/A _4937_/A _4383_/C VGND VGND VPWR VPWR _4384_/C sky130_fd_sc_hd__and3_2
X_3334_ _3330_/Y _3528_/A _5156_/S VGND VGND VPWR VPWR _3334_/Y sky130_fd_sc_hd__o21ai_2
XFILLER_98_543 VGND VGND VPWR VPWR sky130_fd_sc_hd__decap_3
XFILLER_100_504 VGND VGND VPWR VPWR sky130_fd_sc_hd__decap_3
XFILLER_105_39 VGND VGND VPWR VPWR sky130_fd_sc_hd__decap_3
XFILLER_85_215 VGND VGND VPWR VPWR sky130_fd_sc_hd__decap_3
XFILLER_98_587 VGND VGND VPWR VPWR sky130_fd_sc_hd__fill_1
XFILLER_85_237 VGND VGND VPWR VPWR sky130_fd_sc_hd__decap_3
X_5004_ _5004_/A _5004_/B VGND VGND VPWR VPWR _5004_/X sky130_fd_sc_hd__or2_2
XFILLER_26_304 VGND VGND VPWR VPWR sky130_fd_sc_hd__decap_3
XFILLER_38_153 VGND VGND VPWR VPWR sky130_fd_sc_hd__decap_3
XFILLER_39_665 VGND VGND VPWR VPWR sky130_fd_sc_hd__decap_3
XFILLER_39_676 VGND VGND VPWR VPWR sky130_fd_sc_hd__decap_3
XFILLER_54_613 VGND VGND VPWR VPWR sky130_fd_sc_hd__decap_3
XFILLER_66_440 VGND VGND VPWR VPWR sky130_fd_sc_hd__decap_3
XFILLER_66_473 VGND VGND VPWR VPWR sky130_fd_sc_hd__decap_3
XFILLER_38_186 VGND VGND VPWR VPWR sky130_fd_sc_hd__decap_3
XFILLER_38_197 VGND VGND VPWR VPWR sky130_fd_sc_hd__decap_3
XFILLER_54_657 VGND VGND VPWR VPWR sky130_fd_sc_hd__decap_3
X_6955_ _6977_/CLK _6955_/D VGND VGND VPWR VPWR _6955_/Q sky130_fd_sc_hd__dfxtp_2
XPHY_EDGE_ROW_93_Left_210 VGND VGND VPWR VPWR sky130_fd_sc_hd__decap_3
XFILLER_41_329 VGND VGND VPWR VPWR sky130_fd_sc_hd__decap_3
XFILLER_53_178 VGND VGND VPWR VPWR sky130_fd_sc_hd__fill_2
XFILLER_81_476 VGND VGND VPWR VPWR sky130_fd_sc_hd__fill_1
XFILLER_81_487 VGND VGND VPWR VPWR sky130_fd_sc_hd__decap_3
XFILLER_62_690 VGND VGND VPWR VPWR sky130_fd_sc_hd__fill_2
X_6886_ _7005_/CLK _6886_/D VGND VGND VPWR VPWR _6886_/Q sky130_fd_sc_hd__dfxtp_2
XTAP_TAPCELL_ROW_24_538 VGND VPWR sky130_fd_sc_hd__tapvpwrvgnd_1
XFILLER_14_47 VGND VGND VPWR VPWR sky130_fd_sc_hd__decap_3
XFILLER_5_219 VGND VGND VPWR VPWR sky130_fd_sc_hd__decap_3
XFILLER_108_637 VGND VGND VPWR VPWR sky130_fd_sc_hd__decap_3
XFILLER_108_648 VGND VGND VPWR VPWR sky130_fd_sc_hd__decap_3
X_5699_ _7355_/Q hold920/X _5708_/S VGND VGND VPWR VPWR _6699_/D sky130_fd_sc_hd__mux2_2
XFILLER_100_6 VGND VGND VPWR VPWR sky130_fd_sc_hd__decap_3
XFILLER_107_169 VGND VGND VPWR VPWR sky130_fd_sc_hd__decap_3
XFILLER_116_670 VGND VGND VPWR VPWR sky130_fd_sc_hd__fill_2
XFILLER_1_414 VGND VGND VPWR VPWR sky130_fd_sc_hd__decap_3
X_7369_ _7369_/CLK _7369_/D _6649_/Y VGND VGND VPWR VPWR _7369_/Q sky130_fd_sc_hd__dfrtp_2
Xhold750 _6789_/Q VGND VGND VPWR VPWR _6789_/D sky130_fd_sc_hd__dlygate4sd3_1
Xhold761 _6868_/Q VGND VGND VPWR VPWR _6868_/D sky130_fd_sc_hd__dlygate4sd3_1
Xhold772 _6938_/Q VGND VGND VPWR VPWR _6938_/D sky130_fd_sc_hd__dlygate4sd3_1
XTAP_TAPCELL_ROW_73_1131 VGND VPWR sky130_fd_sc_hd__tapvpwrvgnd_1
XFILLER_1_458 VGND VGND VPWR VPWR sky130_fd_sc_hd__decap_3
XFILLER_39_33 VGND VGND VPWR VPWR sky130_fd_sc_hd__fill_1
Xhold783 _6761_/Q VGND VGND VPWR VPWR _6761_/D sky130_fd_sc_hd__dlygate4sd3_1
Xhold794 _6968_/Q VGND VGND VPWR VPWR _6968_/D sky130_fd_sc_hd__dlygate4sd3_1
XFILLER_103_386 VGND VGND VPWR VPWR sky130_fd_sc_hd__decap_3
XFILLER_39_55 VGND VGND VPWR VPWR sky130_fd_sc_hd__fill_1
XFILLER_89_598 VGND VGND VPWR VPWR sky130_fd_sc_hd__decap_3
XFILLER_29_131 VGND VGND VPWR VPWR sky130_fd_sc_hd__decap_3
XFILLER_29_142 VGND VGND VPWR VPWR sky130_fd_sc_hd__decap_3
XFILLER_29_175 VGND VGND VPWR VPWR sky130_fd_sc_hd__decap_3
XFILLER_45_635 VGND VGND VPWR VPWR sky130_fd_sc_hd__decap_3
XFILLER_55_21 VGND VGND VPWR VPWR sky130_fd_sc_hd__decap_3
XFILLER_72_410 VGND VGND VPWR VPWR sky130_fd_sc_hd__decap_3
XFILLER_72_421 VGND VGND VPWR VPWR sky130_fd_sc_hd__decap_3
XTAP_TAPCELL_ROW_4_296 VGND VPWR sky130_fd_sc_hd__tapvpwrvgnd_1
XFILLER_45_668 VGND VGND VPWR VPWR sky130_fd_sc_hd__decap_3
XFILLER_45_679 VGND VGND VPWR VPWR sky130_fd_sc_hd__decap_3
XFILLER_55_54 VGND VGND VPWR VPWR sky130_fd_sc_hd__fill_2
XFILLER_55_87 VGND VGND VPWR VPWR sky130_fd_sc_hd__decap_3
XFILLER_25_370 VGND VGND VPWR VPWR sky130_fd_sc_hd__decap_3
XFILLER_60_616 VGND VGND VPWR VPWR sky130_fd_sc_hd__decap_3
XFILLER_72_498 VGND VGND VPWR VPWR sky130_fd_sc_hd__decap_3
XTAP_TAPCELL_ROW_84_1260 VGND VPWR sky130_fd_sc_hd__tapvpwrvgnd_1
XPHY_EDGE_ROW_105_Right_105 VGND VGND VPWR VPWR sky130_fd_sc_hd__decap_3
XFILLER_111_60 VGND VGND VPWR VPWR sky130_fd_sc_hd__decap_3
XFILLER_25_381 VGND VGND VPWR VPWR sky130_fd_sc_hd__decap_3
XFILLER_71_31 VGND VGND VPWR VPWR sky130_fd_sc_hd__fill_2
XFILLER_111_93 VGND VGND VPWR VPWR sky130_fd_sc_hd__decap_3
XFILLER_13_554 VGND VGND VPWR VPWR sky130_fd_sc_hd__decap_3
XFILLER_40_362 VGND VGND VPWR VPWR sky130_fd_sc_hd__fill_2
XFILLER_9_503 VGND VGND VPWR VPWR sky130_fd_sc_hd__fill_1
XFILLER_9_547 VGND VGND VPWR VPWR sky130_fd_sc_hd__fill_1
XFILLER_65_9 VGND VGND VPWR VPWR sky130_fd_sc_hd__decap_3
XFILLER_114_607 VGND VGND VPWR VPWR sky130_fd_sc_hd__decap_3
XFILLER_113_128 VGND VGND VPWR VPWR sky130_fd_sc_hd__decap_3
XFILLER_99_329 VGND VGND VPWR VPWR sky130_fd_sc_hd__decap_3
XFILLER_96_50 VGND VGND VPWR VPWR sky130_fd_sc_hd__decap_3
XFILLER_95_535 VGND VGND VPWR VPWR sky130_fd_sc_hd__decap_3
XFILLER_96_94 VGND VGND VPWR VPWR sky130_fd_sc_hd__fill_2
XFILLER_48_440 VGND VGND VPWR VPWR sky130_fd_sc_hd__fill_2
XFILLER_75_281 VGND VGND VPWR VPWR sky130_fd_sc_hd__decap_3
XFILLER_35_134 VGND VGND VPWR VPWR sky130_fd_sc_hd__decap_3
Xplace410 _4419_/B1 VGND VGND VPWR VPWR _4429_/B1 sky130_fd_sc_hd__buf_2
Xplace421 _4268_/A2 VGND VGND VPWR VPWR _3968_/S sky130_fd_sc_hd__buf_2
XFILLER_35_167 VGND VGND VPWR VPWR sky130_fd_sc_hd__fill_1
XFILLER_35_178 VGND VGND VPWR VPWR sky130_fd_sc_hd__decap_3
XFILLER_50_115 VGND VGND VPWR VPWR sky130_fd_sc_hd__decap_3
XFILLER_51_638 VGND VGND VPWR VPWR sky130_fd_sc_hd__decap_3
XFILLER_63_498 VGND VGND VPWR VPWR sky130_fd_sc_hd__decap_3
Xplace432 _4459_/C1 VGND VGND VPWR VPWR _4430_/B1 sky130_fd_sc_hd__buf_2
Xplace443 _4960_/A VGND VGND VPWR VPWR _5587_/B sky130_fd_sc_hd__buf_2
Xplace454 _6982_/Q VGND VGND VPWR VPWR _3330_/A sky130_fd_sc_hd__buf_2
X_6740_ _6966_/CLK _6740_/D VGND VGND VPWR VPWR _6740_/Q sky130_fd_sc_hd__dfxtp_2
XFILLER_44_690 VGND VGND VPWR VPWR sky130_fd_sc_hd__fill_2
XFILLER_50_126 VGND VGND VPWR VPWR sky130_fd_sc_hd__decap_3
X_3952_ _7364_/Q _4495_/A0 _3962_/S VGND VGND VPWR VPWR _7364_/D sky130_fd_sc_hd__mux2_2
X_6671_ _6672_/A VGND VGND VPWR VPWR _6671_/Y sky130_fd_sc_hd__inv_2
X_3883_ _6814_/Q _3883_/A2 _3912_/B1 _6819_/Q VGND VGND VPWR VPWR _3883_/X sky130_fd_sc_hd__a22o_2
XTAP_TAPCELL_ROW_21_508 VGND VPWR sky130_fd_sc_hd__tapvpwrvgnd_1
X_5622_ _5622_/A _5633_/B VGND VGND VPWR VPWR _7017_/D sky130_fd_sc_hd__nor2_2
XTAP_TAPCELL_ROW_98_1429 VGND VPWR sky130_fd_sc_hd__tapvpwrvgnd_1
XFILLER_104_128 VGND VGND VPWR VPWR sky130_fd_sc_hd__decap_3
X_7223_ _7356_/CLK _7223_/D _6503_/Y VGND VGND VPWR VPWR _7223_/Q sky130_fd_sc_hd__dfrtp_2
X_4435_ _7207_/Q _3945_/S _4435_/B1 _7367_/Q VGND VGND VPWR VPWR _4435_/X sky130_fd_sc_hd__a22o_2
XFILLER_116_38 VGND VGND VPWR VPWR sky130_fd_sc_hd__decap_3
X_7154_ clkload5/A _7154_/D _6434_/Y VGND VGND VPWR VPWR _7154_/Q sky130_fd_sc_hd__dfrtp_2
X_4366_ _4460_/A _4364_/Y _4313_/D _4361_/A _4365_/X VGND VGND VPWR VPWR _4366_/X
+ sky130_fd_sc_hd__a32o_2
XFILLER_112_150 VGND VGND VPWR VPWR sky130_fd_sc_hd__decap_3
XFILLER_113_662 VGND VGND VPWR VPWR sky130_fd_sc_hd__decap_3
XFILLER_113_673 VGND VGND VPWR VPWR sky130_fd_sc_hd__decap_3
XFILLER_58_215 VGND VGND VPWR VPWR sky130_fd_sc_hd__decap_3
XFILLER_98_351 VGND VGND VPWR VPWR sky130_fd_sc_hd__decap_3
XFILLER_100_312 VGND VGND VPWR VPWR sky130_fd_sc_hd__decap_3
XFILLER_112_183 VGND VGND VPWR VPWR sky130_fd_sc_hd__decap_3
X_7085_ _7266_/CLK _7085_/D _6365_/Y VGND VGND VPWR VPWR _7085_/Q sky130_fd_sc_hd__dfrtp_2
X_4297_ _5113_/A _4297_/B VGND VGND VPWR VPWR _4297_/Y sky130_fd_sc_hd__nor2_2
XFILLER_98_395 VGND VGND VPWR VPWR sky130_fd_sc_hd__decap_3
XFILLER_100_356 VGND VGND VPWR VPWR sky130_fd_sc_hd__decap_3
XFILLER_100_378 VGND VGND VPWR VPWR sky130_fd_sc_hd__decap_3
XFILLER_58_259 VGND VGND VPWR VPWR sky130_fd_sc_hd__decap_3
XFILLER_73_207 VGND VGND VPWR VPWR sky130_fd_sc_hd__decap_3
XFILLER_26_112 VGND VGND VPWR VPWR sky130_fd_sc_hd__decap_3
XFILLER_27_613 VGND VGND VPWR VPWR sky130_fd_sc_hd__decap_3
XFILLER_39_473 VGND VGND VPWR VPWR sky130_fd_sc_hd__decap_3
XTAP_TAPCELL_ROW_57_939 VGND VPWR sky130_fd_sc_hd__tapvpwrvgnd_1
XFILLER_54_432 VGND VGND VPWR VPWR sky130_fd_sc_hd__decap_3
XFILLER_81_240 VGND VGND VPWR VPWR sky130_fd_sc_hd__decap_3
XTAP_TAPCELL_ROW_1_266 VGND VPWR sky130_fd_sc_hd__tapvpwrvgnd_1
XTAP_TAPCELL_ROW_107_1536 VGND VPWR sky130_fd_sc_hd__tapvpwrvgnd_1
XFILLER_14_318 VGND VGND VPWR VPWR sky130_fd_sc_hd__decap_3
XFILLER_25_35 VGND VGND VPWR VPWR sky130_fd_sc_hd__decap_3
XFILLER_26_156 VGND VGND VPWR VPWR sky130_fd_sc_hd__decap_3
XFILLER_26_189 VGND VGND VPWR VPWR sky130_fd_sc_hd__decap_3
XFILLER_42_616 VGND VGND VPWR VPWR sky130_fd_sc_hd__decap_3
XFILLER_81_262 VGND VGND VPWR VPWR sky130_fd_sc_hd__decap_3
XFILLER_25_57 VGND VGND VPWR VPWR sky130_fd_sc_hd__decap_3
XFILLER_25_68 VGND VGND VPWR VPWR sky130_fd_sc_hd__decap_3
XFILLER_35_690 VGND VGND VPWR VPWR sky130_fd_sc_hd__fill_2
XFILLER_81_295 VGND VGND VPWR VPWR sky130_fd_sc_hd__decap_3
X_6938_ _7406_/CLK _6938_/D VGND VGND VPWR VPWR _6938_/Q sky130_fd_sc_hd__dfxtp_2
XTAP_TAPCELL_ROW_37_696 VGND VPWR sky130_fd_sc_hd__tapvpwrvgnd_1
XFILLER_22_362 VGND VGND VPWR VPWR sky130_fd_sc_hd__fill_2
XFILLER_50_660 VGND VGND VPWR VPWR sky130_fd_sc_hd__decap_3
X_6869_ _7384_/CLK _6869_/D VGND VGND VPWR VPWR _6869_/Q sky130_fd_sc_hd__dfxtp_2
XFILLER_41_23 VGND VGND VPWR VPWR sky130_fd_sc_hd__decap_3
XFILLER_108_489 VGND VGND VPWR VPWR sky130_fd_sc_hd__decap_3
XFILLER_104_651 VGND VGND VPWR VPWR sky130_fd_sc_hd__decap_3
XTAP_TAPCELL_ROW_9_355 VGND VPWR sky130_fd_sc_hd__tapvpwrvgnd_1
XFILLER_9_3 VGND VGND VPWR VPWR sky130_fd_sc_hd__decap_3
XFILLER_104_684 VGND VGND VPWR VPWR sky130_fd_sc_hd__decap_3
XFILLER_2_17 VGND VGND VPWR VPWR sky130_fd_sc_hd__decap_3
Xhold591 _6904_/Q VGND VGND VPWR VPWR _6904_/D sky130_fd_sc_hd__dlygate4sd3_1
XFILLER_106_71 VGND VGND VPWR VPWR sky130_fd_sc_hd__decap_3
XFILLER_1_288 VGND VGND VPWR VPWR sky130_fd_sc_hd__fill_1
XFILLER_49_237 VGND VGND VPWR VPWR sky130_fd_sc_hd__decap_3
XFILLER_77_535 VGND VGND VPWR VPWR sky130_fd_sc_hd__decap_3
XFILLER_66_42 VGND VGND VPWR VPWR sky130_fd_sc_hd__decap_3
XFILLER_18_635 VGND VGND VPWR VPWR sky130_fd_sc_hd__decap_3
XFILLER_57_281 VGND VGND VPWR VPWR sky130_fd_sc_hd__decap_3
XFILLER_66_75 VGND VGND VPWR VPWR sky130_fd_sc_hd__fill_1
XFILLER_92_549 VGND VGND VPWR VPWR sky130_fd_sc_hd__decap_3
XFILLER_17_123 VGND VGND VPWR VPWR sky130_fd_sc_hd__decap_3
XFILLER_45_432 VGND VGND VPWR VPWR sky130_fd_sc_hd__decap_3
XFILLER_17_156 VGND VGND VPWR VPWR sky130_fd_sc_hd__decap_3
XFILLER_17_178 VGND VGND VPWR VPWR sky130_fd_sc_hd__decap_3
XFILLER_32_126 VGND VGND VPWR VPWR sky130_fd_sc_hd__decap_3
XFILLER_60_424 VGND VGND VPWR VPWR sky130_fd_sc_hd__fill_1
XFILLER_60_446 VGND VGND VPWR VPWR sky130_fd_sc_hd__decap_3
XFILLER_72_295 VGND VGND VPWR VPWR sky130_fd_sc_hd__fill_1
XFILLER_82_74 VGND VGND VPWR VPWR sky130_fd_sc_hd__decap_3
XFILLER_13_340 VGND VGND VPWR VPWR sky130_fd_sc_hd__fill_2
XFILLER_60_468 VGND VGND VPWR VPWR sky130_fd_sc_hd__decap_3
XFILLER_82_85 VGND VGND VPWR VPWR sky130_fd_sc_hd__decap_3
XFILLER_13_362 VGND VGND VPWR VPWR sky130_fd_sc_hd__decap_3
XFILLER_41_671 VGND VGND VPWR VPWR sky130_fd_sc_hd__fill_1
XFILLER_41_682 VGND VGND VPWR VPWR sky130_fd_sc_hd__decap_3
XFILLER_9_333 VGND VGND VPWR VPWR sky130_fd_sc_hd__decap_3
XFILLER_40_192 VGND VGND VPWR VPWR sky130_fd_sc_hd__decap_3
XFILLER_9_399 VGND VGND VPWR VPWR sky130_fd_sc_hd__fill_1
XFILLER_5_561 VGND VGND VPWR VPWR sky130_fd_sc_hd__decap_3
X_4220_ _7196_/Q _4268_/A2 _4354_/B1 _7388_/Q VGND VGND VPWR VPWR _4220_/X sky130_fd_sc_hd__a22o_2
XFILLER_99_137 VGND VGND VPWR VPWR sky130_fd_sc_hd__decap_3
XFILLER_110_610 VGND VGND VPWR VPWR sky130_fd_sc_hd__decap_3
XFILLER_110_643 VGND VGND VPWR VPWR sky130_fd_sc_hd__fill_1
X_4151_ _7019_/Q _4422_/A2 _3958_/S _7202_/Q _4150_/X VGND VGND VPWR VPWR _4151_/X
+ sky130_fd_sc_hd__a221o_2
XFILLER_110_654 VGND VGND VPWR VPWR sky130_fd_sc_hd__decap_3
XFILLER_55_207 VGND VGND VPWR VPWR sky130_fd_sc_hd__decap_3
XFILLER_83_505 VGND VGND VPWR VPWR sky130_fd_sc_hd__decap_3
XFILLER_95_343 VGND VGND VPWR VPWR sky130_fd_sc_hd__decap_3
X_4082_ _4082_/A _4068_/A VGND VGND VPWR VPWR _4082_/X sky130_fd_sc_hd__or2b_2
XFILLER_110_687 VGND VGND VPWR VPWR sky130_fd_sc_hd__decap_3
XFILLER_102_18 VGND VGND VPWR VPWR sky130_fd_sc_hd__decap_3
XFILLER_36_421 VGND VGND VPWR VPWR sky130_fd_sc_hd__decap_3
XFILLER_51_402 VGND VGND VPWR VPWR sky130_fd_sc_hd__decap_3
XFILLER_63_240 VGND VGND VPWR VPWR sky130_fd_sc_hd__decap_3
XFILLER_51_435 VGND VGND VPWR VPWR sky130_fd_sc_hd__fill_2
XFILLER_63_284 VGND VGND VPWR VPWR sky130_fd_sc_hd__decap_3
Xplace273 _3665_/X VGND VGND VPWR VPWR _3892_/B1 sky130_fd_sc_hd__buf_2
X_4984_ _5099_/A _4619_/Y _4624_/A VGND VGND VPWR VPWR _5031_/B sky130_fd_sc_hd__a21o_2
XFILLER_51_457 VGND VGND VPWR VPWR sky130_fd_sc_hd__decap_3
Xplace295 _3862_/B1 VGND VGND VPWR VPWR _3759_/A2 sky130_fd_sc_hd__buf_2
Xplace284 _3913_/B1 VGND VGND VPWR VPWR _5660_/B sky130_fd_sc_hd__buf_2
X_6723_ _6978_/CLK _6723_/D VGND VGND VPWR VPWR _6723_/Q sky130_fd_sc_hd__dfxtp_2
X_3935_ _7372_/Q _4478_/A0 _3947_/S VGND VGND VPWR VPWR _7372_/D sky130_fd_sc_hd__mux2_2
XTAP_TAPCELL_ROW_34_655 VGND VPWR sky130_fd_sc_hd__tapvpwrvgnd_1
X_6654_ _6683_/A VGND VGND VPWR VPWR _6654_/Y sky130_fd_sc_hd__inv_2
XTAP_TAPCELL_ROW_62_997 VGND VPWR sky130_fd_sc_hd__tapvpwrvgnd_1
XTAP_TAPCELL_ROW_102_1477 VGND VPWR sky130_fd_sc_hd__tapvpwrvgnd_1
XFILLER_31_181 VGND VGND VPWR VPWR sky130_fd_sc_hd__decap_3
X_5605_ _5605_/A _5605_/B VGND VGND VPWR VPWR _7025_/D sky130_fd_sc_hd__or2_2
X_3866_ _6696_/Q _6786_/Q _6874_/Q _6922_/Q _3991_/B _3665_/B VGND VGND VPWR VPWR
+ _3866_/X sky130_fd_sc_hd__mux4_2
XPHY_EDGE_ROW_12_Left_129 VGND VGND VPWR VPWR sky130_fd_sc_hd__decap_3
XFILLER_11_15 VGND VGND VPWR VPWR sky130_fd_sc_hd__decap_3
X_6585_ _6617_/A VGND VGND VPWR VPWR _6585_/Y sky130_fd_sc_hd__inv_2
X_3797_ _6750_/Q _3892_/A2 _3893_/B1 _6732_/Q VGND VGND VPWR VPWR _3797_/X sky130_fd_sc_hd__a22o_2
XFILLER_11_48 VGND VGND VPWR VPWR sky130_fd_sc_hd__decap_3
XFILLER_105_426 VGND VGND VPWR VPWR sky130_fd_sc_hd__decap_3
X_7206_ _7397_/CLK _7206_/D _6486_/Y VGND VGND VPWR VPWR _7206_/Q sky130_fd_sc_hd__dfrtp_2
X_4418_ _7023_/Q _4422_/A2 _4417_/X VGND VGND VPWR VPWR _4425_/C sky130_fd_sc_hd__a21o_2
X_5398_ _5398_/A0 _4997_/X _5417_/S VGND VGND VPWR VPWR _7134_/D sky130_fd_sc_hd__mux2_2
XTAP_TAPCELL_ROW_6_325 VGND VPWR sky130_fd_sc_hd__tapvpwrvgnd_1
XFILLER_99_682 VGND VGND VPWR VPWR sky130_fd_sc_hd__decap_3
XFILLER_99_671 VGND VGND VPWR VPWR sky130_fd_sc_hd__fill_1
XFILLER_113_470 VGND VGND VPWR VPWR sky130_fd_sc_hd__decap_3
X_7137_ _7363_/CLK _7137_/D _6417_/Y VGND VGND VPWR VPWR _7137_/Q sky130_fd_sc_hd__dfrtp_2
X_4349_ _7257_/Q _4356_/A2 _4349_/B1 _7225_/Q _4348_/X VGND VGND VPWR VPWR _4367_/A
+ sky130_fd_sc_hd__a221o_2
XFILLER_98_192 VGND VGND VPWR VPWR sky130_fd_sc_hd__decap_3
XFILLER_101_654 VGND VGND VPWR VPWR sky130_fd_sc_hd__decap_3
XFILLER_101_676 VGND VGND VPWR VPWR sky130_fd_sc_hd__decap_3
XFILLER_86_365 VGND VGND VPWR VPWR sky130_fd_sc_hd__decap_3
X_7068_ clkload9/A _7068_/D _6348_/Y VGND VGND VPWR VPWR _7068_/Q sky130_fd_sc_hd__dfrtp_2
XPHY_EDGE_ROW_21_Left_138 VGND VGND VPWR VPWR sky130_fd_sc_hd__decap_3
XFILLER_36_12 VGND VGND VPWR VPWR sky130_fd_sc_hd__decap_3
XFILLER_74_527 VGND VGND VPWR VPWR sky130_fd_sc_hd__fill_1
XFILLER_74_549 VGND VGND VPWR VPWR sky130_fd_sc_hd__decap_3
XFILLER_100_197 VGND VGND VPWR VPWR sky130_fd_sc_hd__fill_1
XFILLER_36_67 VGND VGND VPWR VPWR sky130_fd_sc_hd__decap_3
XFILLER_54_240 VGND VGND VPWR VPWR sky130_fd_sc_hd__decap_3
XFILLER_54_262 VGND VGND VPWR VPWR sky130_fd_sc_hd__decap_3
XFILLER_82_560 VGND VGND VPWR VPWR sky130_fd_sc_hd__decap_3
XFILLER_82_571 VGND VGND VPWR VPWR sky130_fd_sc_hd__fill_1
XTAP_TAPCELL_ROW_68_1063 VGND VPWR sky130_fd_sc_hd__tapvpwrvgnd_1
XFILLER_15_649 VGND VGND VPWR VPWR sky130_fd_sc_hd__fill_1
XFILLER_54_295 VGND VGND VPWR VPWR sky130_fd_sc_hd__decap_3
XFILLER_23_682 VGND VGND VPWR VPWR sky130_fd_sc_hd__fill_2
XFILLER_52_44 VGND VGND VPWR VPWR sky130_fd_sc_hd__fill_2
XPHY_EDGE_ROW_30_Left_147 VGND VGND VPWR VPWR sky130_fd_sc_hd__decap_3
XFILLER_22_181 VGND VGND VPWR VPWR sky130_fd_sc_hd__decap_3
XFILLER_52_88 VGND VGND VPWR VPWR sky130_fd_sc_hd__decap_3
XFILLER_108_220 VGND VGND VPWR VPWR sky130_fd_sc_hd__decap_3
XFILLER_108_253 VGND VGND VPWR VPWR sky130_fd_sc_hd__decap_3
XFILLER_6_347 VGND VGND VPWR VPWR sky130_fd_sc_hd__fill_2
XFILLER_6_358 VGND VGND VPWR VPWR sky130_fd_sc_hd__decap_3
XFILLER_2_531 VGND VGND VPWR VPWR sky130_fd_sc_hd__fill_1
XFILLER_77_30 VGND VGND VPWR VPWR sky130_fd_sc_hd__decap_3
XFILLER_96_107 VGND VGND VPWR VPWR sky130_fd_sc_hd__decap_3
XFILLER_2_597 VGND VGND VPWR VPWR sky130_fd_sc_hd__decap_3
XFILLER_77_332 VGND VGND VPWR VPWR sky130_fd_sc_hd__decap_3
XFILLER_77_63 VGND VGND VPWR VPWR sky130_fd_sc_hd__decap_3
XFILLER_77_343 VGND VGND VPWR VPWR sky130_fd_sc_hd__fill_2
XFILLER_77_354 VGND VGND VPWR VPWR sky130_fd_sc_hd__decap_3
XFILLER_77_376 VGND VGND VPWR VPWR sky130_fd_sc_hd__decap_3
XFILLER_92_324 VGND VGND VPWR VPWR sky130_fd_sc_hd__decap_3
XFILLER_18_421 VGND VGND VPWR VPWR sky130_fd_sc_hd__decap_3
XFILLER_65_549 VGND VGND VPWR VPWR sky130_fd_sc_hd__fill_1
XFILLER_92_357 VGND VGND VPWR VPWR sky130_fd_sc_hd__decap_3
XFILLER_93_51 VGND VGND VPWR VPWR sky130_fd_sc_hd__decap_3
XFILLER_18_465 VGND VGND VPWR VPWR sky130_fd_sc_hd__decap_3
XFILLER_45_240 VGND VGND VPWR VPWR sky130_fd_sc_hd__decap_3
XFILLER_33_435 VGND VGND VPWR VPWR sky130_fd_sc_hd__decap_3
XFILLER_45_284 VGND VGND VPWR VPWR sky130_fd_sc_hd__decap_3
XFILLER_60_221 VGND VGND VPWR VPWR sky130_fd_sc_hd__fill_2
XFILLER_73_593 VGND VGND VPWR VPWR sky130_fd_sc_hd__decap_3
XFILLER_20_118 VGND VGND VPWR VPWR sky130_fd_sc_hd__decap_3
XFILLER_60_276 VGND VGND VPWR VPWR sky130_fd_sc_hd__decap_3
X_3720_ _6911_/Q _3879_/A2 _3891_/B1 _6903_/Q VGND VGND VPWR VPWR _3720_/X sky130_fd_sc_hd__a22o_2
XTAP_TAPCELL_ROW_31_625 VGND VPWR sky130_fd_sc_hd__tapvpwrvgnd_1
XFILLER_13_181 VGND VGND VPWR VPWR sky130_fd_sc_hd__decap_3
XFILLER_41_490 VGND VGND VPWR VPWR sky130_fd_sc_hd__fill_1
Xclkbuf_leaf_40_clk clkbuf_3_0__f_clk/X VGND VGND VPWR VPWR clkload5/A sky130_fd_sc_hd__clkbuf_16
XFILLER_9_130 VGND VGND VPWR VPWR sky130_fd_sc_hd__decap_3
X_3651_ _3665_/A _3665_/B VGND VGND VPWR VPWR _3651_/Y sky130_fd_sc_hd__nor2_2
XFILLER_61_3 VGND VGND VPWR VPWR sky130_fd_sc_hd__decap_3
X_6370_ _6568_/A VGND VGND VPWR VPWR _6370_/Y sky130_fd_sc_hd__inv_2
X_3582_ _7348_/Q _3449_/X _3407_/X _7124_/Q VGND VGND VPWR VPWR _3583_/C sky130_fd_sc_hd__a22o_2
XTAP_TAPCELL_ROW_11_382 VGND VPWR sky130_fd_sc_hd__tapvpwrvgnd_1
X_5321_ _5321_/A0 _4932_/X _5327_/S VGND VGND VPWR VPWR _7170_/D sky130_fd_sc_hd__mux2_2
XFILLER_114_212 VGND VGND VPWR VPWR sky130_fd_sc_hd__decap_3
XFILLER_114_245 VGND VGND VPWR VPWR sky130_fd_sc_hd__decap_3
XFILLER_102_418 VGND VGND VPWR VPWR sky130_fd_sc_hd__fill_2
X_4203_ _4203_/A _4203_/B _4203_/C VGND VGND VPWR VPWR _4203_/X sky130_fd_sc_hd__and3_2
XFILLER_3_60 VGND VGND VPWR VPWR sky130_fd_sc_hd__decap_3
XFILLER_56_505 VGND VGND VPWR VPWR sky130_fd_sc_hd__decap_3
XFILLER_68_343 VGND VGND VPWR VPWR sky130_fd_sc_hd__decap_3
XFILLER_68_365 VGND VGND VPWR VPWR sky130_fd_sc_hd__decap_3
XFILLER_96_674 VGND VGND VPWR VPWR sky130_fd_sc_hd__decap_3
X_4134_ _7020_/Q _4422_/A2 _3958_/S _7203_/Q _4133_/X VGND VGND VPWR VPWR _4134_/X
+ sky130_fd_sc_hd__a221o_2
XFILLER_3_93 VGND VGND VPWR VPWR sky130_fd_sc_hd__decap_3
XFILLER_56_527 VGND VGND VPWR VPWR sky130_fd_sc_hd__decap_3
XFILLER_68_398 VGND VGND VPWR VPWR sky130_fd_sc_hd__decap_3
XFILLER_95_162 VGND VGND VPWR VPWR sky130_fd_sc_hd__fill_1
XFILLER_95_184 VGND VGND VPWR VPWR sky130_fd_sc_hd__decap_3
XTAP_TAPCELL_ROW_39_725 VGND VPWR sky130_fd_sc_hd__tapvpwrvgnd_1
XTAP_TAPCELL_ROW_39_714 VGND VPWR sky130_fd_sc_hd__tapvpwrvgnd_1
XFILLER_113_39 VGND VGND VPWR VPWR sky130_fd_sc_hd__decap_3
X_4065_ _7052_/Q _4478_/S _4437_/B1 _7404_/Q _4064_/X VGND VGND VPWR VPWR _4065_/X
+ sky130_fd_sc_hd__a221o_2
XFILLER_24_402 VGND VGND VPWR VPWR sky130_fd_sc_hd__decap_3
XFILLER_71_508 VGND VGND VPWR VPWR sky130_fd_sc_hd__decap_3
XFILLER_36_284 VGND VGND VPWR VPWR sky130_fd_sc_hd__decap_3
XFILLER_51_210 VGND VGND VPWR VPWR sky130_fd_sc_hd__decap_3
XFILLER_51_221 VGND VGND VPWR VPWR sky130_fd_sc_hd__decap_3
XTAP_TAPCELL_ROW_19_482 VGND VPWR sky130_fd_sc_hd__tapvpwrvgnd_1
XFILLER_51_287 VGND VGND VPWR VPWR sky130_fd_sc_hd__decap_3
X_4967_ _4967_/A _4967_/B VGND VGND VPWR VPWR _4967_/X sky130_fd_sc_hd__or2_2
Xclkbuf_leaf_31_clk clkbuf_3_2__f_clk/X VGND VGND VPWR VPWR _6964_/CLK sky130_fd_sc_hd__clkbuf_16
X_6706_ _7230_/CLK _6706_/D VGND VGND VPWR VPWR _6706_/Q sky130_fd_sc_hd__dfxtp_2
X_4898_ _4832_/A _3756_/X _4897_/X _5010_/A VGND VGND VPWR VPWR _4898_/X sky130_fd_sc_hd__a211o_2
X_3918_ _6915_/Q _3926_/A2 _3926_/B1 _6779_/Q _3917_/X VGND VGND VPWR VPWR _3918_/X
+ sky130_fd_sc_hd__a221o_2
XFILLER_20_685 VGND VGND VPWR VPWR sky130_fd_sc_hd__decap_3
X_6637_ _6637_/A VGND VGND VPWR VPWR _6637_/Y sky130_fd_sc_hd__inv_2
X_3849_ _6859_/Q _3913_/A2 _3892_/B1 _6899_/Q _3848_/X VGND VGND VPWR VPWR _3849_/X
+ sky130_fd_sc_hd__a221o_2
X_6568_ _6568_/A VGND VGND VPWR VPWR _6568_/Y sky130_fd_sc_hd__inv_2
XTAP_TAPCELL_ROW_115_1635 VGND VPWR sky130_fd_sc_hd__tapvpwrvgnd_1
XFILLER_98_29 VGND VGND VPWR VPWR sky130_fd_sc_hd__decap_3
XFILLER_98_18 VGND VGND VPWR VPWR sky130_fd_sc_hd__fill_2
XFILLER_105_234 VGND VGND VPWR VPWR sky130_fd_sc_hd__decap_3
X_6499_ _6599_/A VGND VGND VPWR VPWR _6499_/Y sky130_fd_sc_hd__inv_2
XFILLER_79_608 VGND VGND VPWR VPWR sky130_fd_sc_hd__decap_3
Xoutput471 place74/X VGND VGND VPWR VPWR alu_result_out[19] sky130_fd_sc_hd__clkdlybuf4s25_1
XFILLER_105_289 VGND VGND VPWR VPWR sky130_fd_sc_hd__decap_3
XFILLER_78_129 VGND VGND VPWR VPWR sky130_fd_sc_hd__decap_3
Xoutput493 _3378_/A VGND VGND VPWR VPWR instruction_out[10] sky130_fd_sc_hd__clkdlybuf4s25_1
Xoutput482 _5653_/Y VGND VGND VPWR VPWR alu_result_out[29] sky130_fd_sc_hd__clkdlybuf4s25_1
XFILLER_47_505 VGND VGND VPWR VPWR sky130_fd_sc_hd__fill_2
XFILLER_59_343 VGND VGND VPWR VPWR sky130_fd_sc_hd__decap_3
XFILLER_101_462 VGND VGND VPWR VPWR sky130_fd_sc_hd__decap_3
XFILLER_47_33 VGND VGND VPWR VPWR sky130_fd_sc_hd__decap_3
XFILLER_47_55 VGND VGND VPWR VPWR sky130_fd_sc_hd__fill_1
XFILLER_59_387 VGND VGND VPWR VPWR sky130_fd_sc_hd__decap_3
XFILLER_86_162 VGND VGND VPWR VPWR sky130_fd_sc_hd__decap_3
XFILLER_86_173 VGND VGND VPWR VPWR sky130_fd_sc_hd__decap_3
XFILLER_87_685 VGND VGND VPWR VPWR sky130_fd_sc_hd__decap_3
XFILLER_101_495 VGND VGND VPWR VPWR sky130_fd_sc_hd__decap_3
XFILLER_47_66 VGND VGND VPWR VPWR sky130_fd_sc_hd__decap_3
XFILLER_74_357 VGND VGND VPWR VPWR sky130_fd_sc_hd__decap_3
XFILLER_27_240 VGND VGND VPWR VPWR sky130_fd_sc_hd__fill_2
XFILLER_27_251 VGND VGND VPWR VPWR sky130_fd_sc_hd__decap_3
XFILLER_47_99 VGND VGND VPWR VPWR sky130_fd_sc_hd__fill_1
XFILLER_74_368 VGND VGND VPWR VPWR sky130_fd_sc_hd__fill_2
XFILLER_103_72 VGND VGND VPWR VPWR sky130_fd_sc_hd__decap_3
XFILLER_27_284 VGND VGND VPWR VPWR sky130_fd_sc_hd__decap_3
XFILLER_63_21 VGND VGND VPWR VPWR sky130_fd_sc_hd__decap_3
XFILLER_30_405 VGND VGND VPWR VPWR sky130_fd_sc_hd__decap_3
XFILLER_30_438 VGND VGND VPWR VPWR sky130_fd_sc_hd__fill_1
XFILLER_42_265 VGND VGND VPWR VPWR sky130_fd_sc_hd__decap_3
XFILLER_63_87 VGND VGND VPWR VPWR sky130_fd_sc_hd__fill_2
XFILLER_8_38 VGND VGND VPWR VPWR sky130_fd_sc_hd__decap_3
Xclkbuf_leaf_22_clk clkload1/A VGND VGND VPWR VPWR _6931_/CLK sky130_fd_sc_hd__clkbuf_16
XFILLER_6_100 VGND VGND VPWR VPWR sky130_fd_sc_hd__decap_3
XFILLER_109_551 VGND VGND VPWR VPWR sky130_fd_sc_hd__decap_3
XFILLER_10_195 VGND VGND VPWR VPWR sky130_fd_sc_hd__fill_1
XFILLER_6_133 VGND VGND VPWR VPWR sky130_fd_sc_hd__decap_3
XFILLER_6_144 VGND VGND VPWR VPWR sky130_fd_sc_hd__decap_3
XFILLER_88_40 VGND VGND VPWR VPWR sky130_fd_sc_hd__decap_3
XFILLER_69_107 VGND VGND VPWR VPWR sky130_fd_sc_hd__decap_3
XFILLER_88_73 VGND VGND VPWR VPWR sky130_fd_sc_hd__decap_3
XTAP_TAPCELL_ROW_90_1329 VGND VPWR sky130_fd_sc_hd__tapvpwrvgnd_1
XFILLER_2_383 VGND VGND VPWR VPWR sky130_fd_sc_hd__decap_3
XFILLER_97_438 VGND VGND VPWR VPWR sky130_fd_sc_hd__decap_3
XFILLER_26_6 VGND VGND VPWR VPWR sky130_fd_sc_hd__decap_3
XFILLER_65_302 VGND VGND VPWR VPWR sky130_fd_sc_hd__decap_3
XFILLER_65_335 VGND VGND VPWR VPWR sky130_fd_sc_hd__fill_1
XFILLER_65_346 VGND VGND VPWR VPWR sky130_fd_sc_hd__decap_3
XFILLER_92_132 VGND VGND VPWR VPWR sky130_fd_sc_hd__decap_3
XFILLER_93_644 VGND VGND VPWR VPWR sky130_fd_sc_hd__decap_3
XFILLER_18_251 VGND VGND VPWR VPWR sky130_fd_sc_hd__fill_1
XFILLER_80_305 VGND VGND VPWR VPWR sky130_fd_sc_hd__decap_3
XFILLER_92_154 VGND VGND VPWR VPWR sky130_fd_sc_hd__fill_2
X_4821_ _4832_/A _3704_/X _4819_/X _5010_/A VGND VGND VPWR VPWR _4821_/X sky130_fd_sc_hd__a211o_2
XTAP_TAPCELL_ROW_16_441 VGND VPWR sky130_fd_sc_hd__tapvpwrvgnd_1
XTAP_TAPCELL_ROW_44_783 VGND VPWR sky130_fd_sc_hd__tapvpwrvgnd_1
Xclkbuf_leaf_13_clk clkload3/A VGND VGND VPWR VPWR _7338_/CLK sky130_fd_sc_hd__clkbuf_16
X_4752_ _4997_/A1 _7006_/D _4751_/Y VGND VGND VPWR VPWR _4752_/X sky130_fd_sc_hd__a21o_2
X_4683_ _6997_/Q _6998_/Q _5605_/B VGND VGND VPWR VPWR _4683_/X sky130_fd_sc_hd__o21a_2
X_3703_ _6938_/Q _3902_/A2 _3862_/B1 _6802_/Q VGND VGND VPWR VPWR _3703_/X sky130_fd_sc_hd__a22o_2
X_6422_ _6616_/A VGND VGND VPWR VPWR _6422_/Y sky130_fd_sc_hd__inv_2
X_3634_ _3636_/B _3631_/Y _3632_/X _3633_/Y VGND VGND VPWR VPWR _3634_/Y sky130_fd_sc_hd__o211ai_4
X_6353_ _6388_/A VGND VGND VPWR VPWR _6353_/Y sky130_fd_sc_hd__inv_2
X_3565_ _3469_/A _3469_/B _3564_/X _3449_/A VGND VGND VPWR VPWR _5648_/B sky130_fd_sc_hd__o211a_2
XFILLER_0_309 VGND VGND VPWR VPWR sky130_fd_sc_hd__decap_3
XFILLER_115_554 VGND VGND VPWR VPWR sky130_fd_sc_hd__decap_3
XFILLER_115_576 VGND VGND VPWR VPWR sky130_fd_sc_hd__decap_3
X_6284_ _6285_/A VGND VGND VPWR VPWR _6284_/Y sky130_fd_sc_hd__inv_2
X_5304_ _5304_/A0 _4792_/X _5323_/S VGND VGND VPWR VPWR _7178_/D sky130_fd_sc_hd__mux2_2
X_3496_ _7215_/Q _4230_/A2 _5126_/S _7279_/Q _3495_/X VGND VGND VPWR VPWR _3496_/X
+ sky130_fd_sc_hd__a221o_2
XFILLER_69_630 VGND VGND VPWR VPWR sky130_fd_sc_hd__decap_3
XFILLER_88_427 VGND VGND VPWR VPWR sky130_fd_sc_hd__decap_3
XFILLER_69_663 VGND VGND VPWR VPWR sky130_fd_sc_hd__decap_3
XFILLER_29_516 VGND VGND VPWR VPWR sky130_fd_sc_hd__decap_3
XFILLER_68_162 VGND VGND VPWR VPWR sky130_fd_sc_hd__decap_3
XFILLER_69_685 VGND VGND VPWR VPWR sky130_fd_sc_hd__decap_3
XTAP_TAPCELL_ROW_110_1576 VGND VPWR sky130_fd_sc_hd__tapvpwrvgnd_1
XFILLER_56_324 VGND VGND VPWR VPWR sky130_fd_sc_hd__fill_2
XFILLER_56_346 VGND VGND VPWR VPWR sky130_fd_sc_hd__decap_3
XFILLER_68_195 VGND VGND VPWR VPWR sky130_fd_sc_hd__fill_1
XFILLER_83_110 VGND VGND VPWR VPWR sky130_fd_sc_hd__fill_2
XFILLER_84_633 VGND VGND VPWR VPWR sky130_fd_sc_hd__decap_3
X_5097_ _6985_/Q _5120_/A VGND VGND VPWR VPWR _5098_/B sky130_fd_sc_hd__nor2_2
X_4117_ _4205_/A _4117_/B _4117_/C VGND VGND VPWR VPWR _4117_/Y sky130_fd_sc_hd__nand3_2
XFILLER_17_36 VGND VGND VPWR VPWR sky130_fd_sc_hd__decap_3
XFILLER_56_368 VGND VGND VPWR VPWR sky130_fd_sc_hd__decap_3
XFILLER_83_143 VGND VGND VPWR VPWR sky130_fd_sc_hd__decap_3
XFILLER_84_688 VGND VGND VPWR VPWR sky130_fd_sc_hd__decap_3
X_4048_ _7117_/Q _4434_/A2 _4434_/B1 _7149_/Q VGND VGND VPWR VPWR _4048_/X sky130_fd_sc_hd__a22o_2
XFILLER_24_221 VGND VGND VPWR VPWR sky130_fd_sc_hd__decap_3
XFILLER_24_243 VGND VGND VPWR VPWR sky130_fd_sc_hd__fill_1
XFILLER_52_541 VGND VGND VPWR VPWR sky130_fd_sc_hd__fill_2
XFILLER_64_390 VGND VGND VPWR VPWR sky130_fd_sc_hd__fill_1
XTAP_TAPCELL_ROW_65_1033 VGND VPWR sky130_fd_sc_hd__tapvpwrvgnd_1
XFILLER_12_416 VGND VGND VPWR VPWR sky130_fd_sc_hd__decap_3
XFILLER_24_265 VGND VGND VPWR VPWR sky130_fd_sc_hd__decap_3
XPHY_EDGE_ROW_104_Left_221 VGND VGND VPWR VPWR sky130_fd_sc_hd__decap_3
XFILLER_109_3 VGND VGND VPWR VPWR sky130_fd_sc_hd__decap_3
XFILLER_3_125 VGND VGND VPWR VPWR sky130_fd_sc_hd__decap_3
XFILLER_4_648 VGND VGND VPWR VPWR sky130_fd_sc_hd__decap_3
XFILLER_106_554 VGND VGND VPWR VPWR sky130_fd_sc_hd__fill_2
XFILLER_3_169 VGND VGND VPWR VPWR sky130_fd_sc_hd__fill_2
XFILLER_79_405 VGND VGND VPWR VPWR sky130_fd_sc_hd__decap_3
XTAP_TAPCELL_ROW_76_1162 VGND VPWR sky130_fd_sc_hd__tapvpwrvgnd_1
XFILLER_79_449 VGND VGND VPWR VPWR sky130_fd_sc_hd__decap_3
XFILLER_58_32 VGND VGND VPWR VPWR sky130_fd_sc_hd__decap_3
XFILLER_59_151 VGND VGND VPWR VPWR sky130_fd_sc_hd__decap_3
XFILLER_87_471 VGND VGND VPWR VPWR sky130_fd_sc_hd__decap_3
XPHY_EDGE_ROW_113_Left_230 VGND VGND VPWR VPWR sky130_fd_sc_hd__decap_3
XFILLER_101_270 VGND VGND VPWR VPWR sky130_fd_sc_hd__decap_3
XFILLER_101_281 VGND VGND VPWR VPWR sky130_fd_sc_hd__fill_1
XFILLER_47_324 VGND VGND VPWR VPWR sky130_fd_sc_hd__decap_3
XFILLER_59_184 VGND VGND VPWR VPWR sky130_fd_sc_hd__decap_3
XFILLER_114_71 VGND VGND VPWR VPWR sky130_fd_sc_hd__decap_3
XFILLER_74_20 VGND VGND VPWR VPWR sky130_fd_sc_hd__decap_3
XFILLER_75_688 VGND VGND VPWR VPWR sky130_fd_sc_hd__decap_3
XFILLER_74_53 VGND VGND VPWR VPWR sky130_fd_sc_hd__decap_3
XFILLER_74_64 VGND VGND VPWR VPWR sky130_fd_sc_hd__decap_3
XFILLER_90_658 VGND VGND VPWR VPWR sky130_fd_sc_hd__decap_3
XTAP_TAPCELL_ROW_87_1291 VGND VPWR sky130_fd_sc_hd__tapvpwrvgnd_1
XFILLER_15_276 VGND VGND VPWR VPWR sky130_fd_sc_hd__decap_3
XFILLER_15_287 VGND VGND VPWR VPWR sky130_fd_sc_hd__decap_3
XFILLER_95_9 VGND VGND VPWR VPWR sky130_fd_sc_hd__decap_3
XFILLER_30_224 VGND VGND VPWR VPWR sky130_fd_sc_hd__decap_3
XTAP_TAPCELL_ROW_41_742 VGND VPWR sky130_fd_sc_hd__tapvpwrvgnd_1
XTAP_TAPCELL_ROW_13_411 VGND VPWR sky130_fd_sc_hd__tapvpwrvgnd_1
XFILLER_90_85 VGND VGND VPWR VPWR sky130_fd_sc_hd__decap_3
XFILLER_11_493 VGND VGND VPWR VPWR sky130_fd_sc_hd__decap_3
XFILLER_116_307 VGND VGND VPWR VPWR sky130_fd_sc_hd__fill_1
XFILLER_116_318 VGND VGND VPWR VPWR sky130_fd_sc_hd__fill_2
XFILLER_99_72 VGND VGND VPWR VPWR sky130_fd_sc_hd__decap_3
X_3350_ _6979_/Q _3350_/B VGND VGND VPWR VPWR _3350_/Y sky130_fd_sc_hd__nor2_2
XFILLER_112_524 VGND VGND VPWR VPWR sky130_fd_sc_hd__decap_3
XFILLER_85_408 VGND VGND VPWR VPWR sky130_fd_sc_hd__fill_1
XFILLER_97_246 VGND VGND VPWR VPWR sky130_fd_sc_hd__decap_3
X_5020_ _5020_/A _5020_/B _4373_/Y VGND VGND VPWR VPWR _5020_/X sky130_fd_sc_hd__or3b_2
XFILLER_66_622 VGND VGND VPWR VPWR sky130_fd_sc_hd__decap_3
XFILLER_78_460 VGND VGND VPWR VPWR sky130_fd_sc_hd__fill_2
XFILLER_78_471 VGND VGND VPWR VPWR sky130_fd_sc_hd__decap_3
XFILLER_97_279 VGND VGND VPWR VPWR sky130_fd_sc_hd__fill_1
Xclkbuf_leaf_2_clk clkbuf_leaf_4_clk/A VGND VGND VPWR VPWR _7358_/CLK sky130_fd_sc_hd__clkbuf_16
Xhold1109 _7308_/Q VGND VGND VPWR VPWR _4544_/A sky130_fd_sc_hd__dlygate4sd3_1
XFILLER_38_346 VGND VGND VPWR VPWR sky130_fd_sc_hd__decap_3
XFILLER_65_110 VGND VGND VPWR VPWR sky130_fd_sc_hd__fill_2
XFILLER_65_132 VGND VGND VPWR VPWR sky130_fd_sc_hd__decap_3
XTAP_TAPCELL_ROW_49_842 VGND VPWR sky130_fd_sc_hd__tapvpwrvgnd_1
XFILLER_38_368 VGND VGND VPWR VPWR sky130_fd_sc_hd__decap_3
XFILLER_65_165 VGND VGND VPWR VPWR sky130_fd_sc_hd__decap_3
XFILLER_66_666 VGND VGND VPWR VPWR sky130_fd_sc_hd__decap_3
XFILLER_0_50 VGND VGND VPWR VPWR sky130_fd_sc_hd__decap_3
XFILLER_19_593 VGND VGND VPWR VPWR sky130_fd_sc_hd__fill_2
XFILLER_53_327 VGND VGND VPWR VPWR sky130_fd_sc_hd__decap_3
XFILLER_65_187 VGND VGND VPWR VPWR sky130_fd_sc_hd__decap_3
XFILLER_80_124 VGND VGND VPWR VPWR sky130_fd_sc_hd__decap_3
XFILLER_93_485 VGND VGND VPWR VPWR sky130_fd_sc_hd__fill_2
XFILLER_93_496 VGND VGND VPWR VPWR sky130_fd_sc_hd__fill_2
X_6971_ _6976_/CLK _6971_/D VGND VGND VPWR VPWR _6971_/Q sky130_fd_sc_hd__dfxtp_2
XFILLER_0_83 VGND VGND VPWR VPWR sky130_fd_sc_hd__fill_1
XFILLER_81_658 VGND VGND VPWR VPWR sky130_fd_sc_hd__decap_3
XFILLER_110_18 VGND VGND VPWR VPWR sky130_fd_sc_hd__decap_3
XFILLER_110_29 VGND VGND VPWR VPWR sky130_fd_sc_hd__decap_3
XFILLER_21_202 VGND VGND VPWR VPWR sky130_fd_sc_hd__decap_3
XFILLER_80_168 VGND VGND VPWR VPWR sky130_fd_sc_hd__decap_3
XFILLER_21_246 VGND VGND VPWR VPWR sky130_fd_sc_hd__decap_3
XFILLER_61_393 VGND VGND VPWR VPWR sky130_fd_sc_hd__decap_3
X_4804_ _4804_/A _4804_/B VGND VGND VPWR VPWR _4804_/X sky130_fd_sc_hd__or2_2
X_4735_ _4735_/A0 _4734_/X _4772_/S VGND VGND VPWR VPWR _7277_/D sky130_fd_sc_hd__mux2_2
XFILLER_9_81 VGND VGND VPWR VPWR sky130_fd_sc_hd__decap_3
XFILLER_107_307 VGND VGND VPWR VPWR sky130_fd_sc_hd__decap_3
X_4666_ _6997_/Q _4667_/B VGND VGND VPWR VPWR _4908_/A sky130_fd_sc_hd__xnor2_2
X_7385_ _7392_/CLK _7385_/D _6665_/Y VGND VGND VPWR VPWR _7385_/Q sky130_fd_sc_hd__dfrtp_2
Xhold910 _6687_/Q VGND VGND VPWR VPWR hold910/X sky130_fd_sc_hd__dlygate4sd3_1
Xhold921 _7021_/Q VGND VGND VPWR VPWR _5613_/A sky130_fd_sc_hd__dlygate4sd3_1
X_6405_ _6567_/A VGND VGND VPWR VPWR _6405_/Y sky130_fd_sc_hd__inv_2
X_4597_ _7282_/Q _5140_/A0 _4601_/S VGND VGND VPWR VPWR _7282_/D sky130_fd_sc_hd__mux2_2
X_3617_ _4614_/C _3616_/B _5146_/B1 VGND VGND VPWR VPWR _3617_/X sky130_fd_sc_hd__o21a_2
XFILLER_115_340 VGND VGND VPWR VPWR sky130_fd_sc_hd__decap_3
Xhold932 _6704_/Q VGND VGND VPWR VPWR hold932/X sky130_fd_sc_hd__dlygate4sd3_1
Xhold954 _7045_/Q VGND VGND VPWR VPWR hold954/X sky130_fd_sc_hd__dlygate4sd3_1
Xhold943 _6695_/Q VGND VGND VPWR VPWR hold943/X sky130_fd_sc_hd__dlygate4sd3_1
X_6336_ _6347_/A VGND VGND VPWR VPWR _6336_/Y sky130_fd_sc_hd__inv_2
X_3548_ _3621_/A _4938_/A _5072_/A VGND VGND VPWR VPWR _3548_/X sky130_fd_sc_hd__or3_2
XFILLER_1_629 VGND VGND VPWR VPWR sky130_fd_sc_hd__decap_3
XFILLER_88_224 VGND VGND VPWR VPWR sky130_fd_sc_hd__decap_3
Xhold998 _7027_/Q VGND VGND VPWR VPWR _5600_/A sky130_fd_sc_hd__dlygate4sd3_1
Xhold987 _7024_/Q VGND VGND VPWR VPWR _5607_/A sky130_fd_sc_hd__dlygate4sd3_1
Xhold976 _7380_/Q VGND VGND VPWR VPWR hold976/X sky130_fd_sc_hd__dlygate4sd3_1
Xhold965 _7022_/Q VGND VGND VPWR VPWR _5611_/A sky130_fd_sc_hd__dlygate4sd3_1
X_6267_ _6366_/A VGND VGND VPWR VPWR _6267_/Y sky130_fd_sc_hd__inv_2
X_3479_ _7152_/Q _4352_/B1 _3478_/X VGND VGND VPWR VPWR _3482_/A sky130_fd_sc_hd__a21o_2
XFILLER_103_579 VGND VGND VPWR VPWR sky130_fd_sc_hd__decap_3
XFILLER_29_302 VGND VGND VPWR VPWR sky130_fd_sc_hd__decap_3
XFILLER_57_611 VGND VGND VPWR VPWR sky130_fd_sc_hd__decap_3
XFILLER_88_268 VGND VGND VPWR VPWR sky130_fd_sc_hd__decap_3
XFILLER_28_57 VGND VGND VPWR VPWR sky130_fd_sc_hd__decap_3
XFILLER_29_346 VGND VGND VPWR VPWR sky130_fd_sc_hd__fill_1
XFILLER_56_121 VGND VGND VPWR VPWR sky130_fd_sc_hd__decap_3
XFILLER_57_644 VGND VGND VPWR VPWR sky130_fd_sc_hd__decap_3
XFILLER_84_430 VGND VGND VPWR VPWR sky130_fd_sc_hd__decap_3
XFILLER_96_290 VGND VGND VPWR VPWR sky130_fd_sc_hd__decap_3
X_5149_ _5145_/A _4852_/A _5147_/X _5148_/X VGND VGND VPWR VPWR _5149_/Y sky130_fd_sc_hd__o211ai_2
XFILLER_17_508 VGND VGND VPWR VPWR sky130_fd_sc_hd__decap_3
XFILLER_44_305 VGND VGND VPWR VPWR sky130_fd_sc_hd__decap_3
XFILLER_57_688 VGND VGND VPWR VPWR sky130_fd_sc_hd__decap_3
XFILLER_84_463 VGND VGND VPWR VPWR sky130_fd_sc_hd__decap_3
XFILLER_44_327 VGND VGND VPWR VPWR sky130_fd_sc_hd__decap_3
XFILLER_71_113 VGND VGND VPWR VPWR sky130_fd_sc_hd__fill_2
XFILLER_25_530 VGND VGND VPWR VPWR sky130_fd_sc_hd__decap_3
XFILLER_44_12 VGND VGND VPWR VPWR sky130_fd_sc_hd__decap_3
XFILLER_71_135 VGND VGND VPWR VPWR sky130_fd_sc_hd__decap_3
XFILLER_40_511 VGND VGND VPWR VPWR sky130_fd_sc_hd__decap_3
XFILLER_44_67 VGND VGND VPWR VPWR sky130_fd_sc_hd__decap_3
XFILLER_40_533 VGND VGND VPWR VPWR sky130_fd_sc_hd__decap_3
XFILLER_100_62 VGND VGND VPWR VPWR sky130_fd_sc_hd__decap_3
XFILLER_8_217 VGND VGND VPWR VPWR sky130_fd_sc_hd__decap_3
XFILLER_60_66 VGND VGND VPWR VPWR sky130_fd_sc_hd__decap_3
XFILLER_60_88 VGND VGND VPWR VPWR sky130_fd_sc_hd__decap_3
XFILLER_109_60 VGND VGND VPWR VPWR sky130_fd_sc_hd__decap_3
XFILLER_4_467 VGND VGND VPWR VPWR sky130_fd_sc_hd__decap_3
XFILLER_5_39 VGND VGND VPWR VPWR sky130_fd_sc_hd__decap_3
XFILLER_109_93 VGND VGND VPWR VPWR sky130_fd_sc_hd__decap_3
XFILLER_69_42 VGND VGND VPWR VPWR sky130_fd_sc_hd__fill_1
XFILLER_69_75 VGND VGND VPWR VPWR sky130_fd_sc_hd__decap_3
XFILLER_0_651 VGND VGND VPWR VPWR sky130_fd_sc_hd__decap_3
XFILLER_0_673 VGND VGND VPWR VPWR sky130_fd_sc_hd__decap_3
XFILLER_79_268 VGND VGND VPWR VPWR sky130_fd_sc_hd__decap_3
XFILLER_10_9 VGND VGND VPWR VPWR sky130_fd_sc_hd__decap_3
XFILLER_48_633 VGND VGND VPWR VPWR sky130_fd_sc_hd__decap_3
XFILLER_94_227 VGND VGND VPWR VPWR sky130_fd_sc_hd__fill_2
XFILLER_94_238 VGND VGND VPWR VPWR sky130_fd_sc_hd__decap_3
XFILLER_94_249 VGND VGND VPWR VPWR sky130_fd_sc_hd__decap_3
XTAP_TAPCELL_ROW_89_1320 VGND VPWR sky130_fd_sc_hd__tapvpwrvgnd_1
XFILLER_48_666 VGND VGND VPWR VPWR sky130_fd_sc_hd__decap_3
XFILLER_75_441 VGND VGND VPWR VPWR sky130_fd_sc_hd__decap_3
XFILLER_75_452 VGND VGND VPWR VPWR sky130_fd_sc_hd__decap_3
XTAP_TAPCELL_ROW_46_801 VGND VPWR sky130_fd_sc_hd__tapvpwrvgnd_1
XFILLER_63_647 VGND VGND VPWR VPWR sky130_fd_sc_hd__decap_3
XFILLER_75_485 VGND VGND VPWR VPWR sky130_fd_sc_hd__decap_3
XFILLER_85_96 VGND VGND VPWR VPWR sky130_fd_sc_hd__decap_3
XFILLER_35_349 VGND VGND VPWR VPWR sky130_fd_sc_hd__fill_1
XFILLER_62_135 VGND VGND VPWR VPWR sky130_fd_sc_hd__decap_3
XFILLER_31_511 VGND VGND VPWR VPWR sky130_fd_sc_hd__decap_3
XFILLER_43_393 VGND VGND VPWR VPWR sky130_fd_sc_hd__decap_3
XFILLER_70_190 VGND VGND VPWR VPWR sky130_fd_sc_hd__decap_3
XFILLER_71_691 VGND VGND VPWR VPWR sky130_fd_sc_hd__fill_1
XFILLER_93_6 VGND VGND VPWR VPWR sky130_fd_sc_hd__decap_3
XFILLER_11_290 VGND VGND VPWR VPWR sky130_fd_sc_hd__fill_1
X_4520_ _4520_/A0 _7287_/Q _4528_/B VGND VGND VPWR VPWR _7319_/D sky130_fd_sc_hd__mux2_2
XFILLER_116_126 VGND VGND VPWR VPWR sky130_fd_sc_hd__decap_3
X_4451_ _4451_/A _4451_/B VGND VGND VPWR VPWR _4765_/B sky130_fd_sc_hd__nor2_2
X_7170_ _7267_/CLK _7170_/D _6450_/Y VGND VGND VPWR VPWR _7170_/Q sky130_fd_sc_hd__dfrtp_2
X_3402_ _3385_/Y _3401_/X _4230_/A2 VGND VGND VPWR VPWR _3421_/C sky130_fd_sc_hd__a21oi_4
X_4382_ _4950_/A _4967_/B VGND VGND VPWR VPWR _4383_/C sky130_fd_sc_hd__nor2_2
XFILLER_98_533 VGND VGND VPWR VPWR sky130_fd_sc_hd__decap_3
XFILLER_98_500 VGND VGND VPWR VPWR sky130_fd_sc_hd__decap_3
XFILLER_112_343 VGND VGND VPWR VPWR sky130_fd_sc_hd__decap_3
XFILLER_98_555 VGND VGND VPWR VPWR sky130_fd_sc_hd__decap_3
XFILLER_100_516 VGND VGND VPWR VPWR sky130_fd_sc_hd__decap_3
XFILLER_105_18 VGND VGND VPWR VPWR sky130_fd_sc_hd__decap_3
XFILLER_112_365 VGND VGND VPWR VPWR sky130_fd_sc_hd__decap_3
XFILLER_112_376 VGND VGND VPWR VPWR sky130_fd_sc_hd__decap_3
XFILLER_58_419 VGND VGND VPWR VPWR sky130_fd_sc_hd__fill_1
XPHY_EDGE_ROW_7_Right_7 VGND VGND VPWR VPWR sky130_fd_sc_hd__decap_3
XFILLER_100_549 VGND VGND VPWR VPWR sky130_fd_sc_hd__decap_3
XFILLER_66_430 VGND VGND VPWR VPWR sky130_fd_sc_hd__fill_1
XFILLER_85_249 VGND VGND VPWR VPWR sky130_fd_sc_hd__decap_3
X_5003_ _5003_/A _5003_/B VGND VGND VPWR VPWR _5003_/X sky130_fd_sc_hd__or2_2
XFILLER_38_165 VGND VGND VPWR VPWR sky130_fd_sc_hd__decap_3
XFILLER_39_688 VGND VGND VPWR VPWR sky130_fd_sc_hd__decap_3
XFILLER_54_625 VGND VGND VPWR VPWR sky130_fd_sc_hd__decap_3
XFILLER_93_260 VGND VGND VPWR VPWR sky130_fd_sc_hd__decap_3
XFILLER_53_124 VGND VGND VPWR VPWR sky130_fd_sc_hd__decap_3
XFILLER_53_157 VGND VGND VPWR VPWR sky130_fd_sc_hd__decap_3
XFILLER_54_669 VGND VGND VPWR VPWR sky130_fd_sc_hd__decap_3
XFILLER_81_455 VGND VGND VPWR VPWR sky130_fd_sc_hd__decap_3
X_6954_ _6966_/CLK _6954_/D VGND VGND VPWR VPWR _6954_/Q sky130_fd_sc_hd__dfxtp_2
XFILLER_41_308 VGND VGND VPWR VPWR sky130_fd_sc_hd__decap_3
XFILLER_81_499 VGND VGND VPWR VPWR sky130_fd_sc_hd__decap_3
XFILLER_14_15 VGND VGND VPWR VPWR sky130_fd_sc_hd__decap_3
XFILLER_34_382 VGND VGND VPWR VPWR sky130_fd_sc_hd__decap_3
X_6885_ _7005_/CLK _6885_/D VGND VGND VPWR VPWR _6885_/Q sky130_fd_sc_hd__dfxtp_2
XTAP_TAPCELL_ROW_24_539 VGND VPWR sky130_fd_sc_hd__tapvpwrvgnd_1
XFILLER_61_190 VGND VGND VPWR VPWR sky130_fd_sc_hd__decap_3
XFILLER_30_14 VGND VGND VPWR VPWR sky130_fd_sc_hd__decap_3
X_4718_ _4718_/A0 _4716_/X _4772_/S VGND VGND VPWR VPWR _7278_/D sky130_fd_sc_hd__mux2_4
XFILLER_107_126 VGND VGND VPWR VPWR sky130_fd_sc_hd__decap_3
X_4649_ _4649_/A _4649_/B _4425_/C VGND VGND VPWR VPWR _4652_/A sky130_fd_sc_hd__nor3b_2
XFILLER_30_69 VGND VGND VPWR VPWR sky130_fd_sc_hd__fill_1
XFILLER_116_660 VGND VGND VPWR VPWR sky130_fd_sc_hd__fill_2
XFILLER_116_682 VGND VGND VPWR VPWR sky130_fd_sc_hd__fill_2
XFILLER_1_426 VGND VGND VPWR VPWR sky130_fd_sc_hd__decap_3
X_7368_ _7368_/CLK _7368_/D _6648_/Y VGND VGND VPWR VPWR _7368_/Q sky130_fd_sc_hd__dfrtp_2
Xhold740 _6830_/Q VGND VGND VPWR VPWR _6830_/D sky130_fd_sc_hd__dlygate4sd3_1
Xhold751 _6867_/Q VGND VGND VPWR VPWR _6867_/D sky130_fd_sc_hd__dlygate4sd3_1
Xhold762 _6754_/Q VGND VGND VPWR VPWR _6754_/D sky130_fd_sc_hd__dlygate4sd3_1
Xhold773 _6971_/Q VGND VGND VPWR VPWR _6971_/D sky130_fd_sc_hd__dlygate4sd3_1
XTAP_TAPCELL_ROW_73_1132 VGND VPWR sky130_fd_sc_hd__tapvpwrvgnd_1
XFILLER_103_310 VGND VGND VPWR VPWR sky130_fd_sc_hd__decap_3
XFILLER_115_181 VGND VGND VPWR VPWR sky130_fd_sc_hd__decap_3
XFILLER_1_437 VGND VGND VPWR VPWR sky130_fd_sc_hd__decap_3
X_7299_ _7363_/CLK _7299_/D _6579_/Y VGND VGND VPWR VPWR _7299_/Q sky130_fd_sc_hd__dfrtp_2
Xhold784 _6970_/Q VGND VGND VPWR VPWR _6970_/D sky130_fd_sc_hd__dlygate4sd3_1
Xhold795 _6757_/Q VGND VGND VPWR VPWR _6757_/D sky130_fd_sc_hd__dlygate4sd3_1
X_6319_ _6674_/A VGND VGND VPWR VPWR _6319_/Y sky130_fd_sc_hd__inv_2
XFILLER_89_588 VGND VGND VPWR VPWR sky130_fd_sc_hd__fill_1
XFILLER_29_110 VGND VGND VPWR VPWR sky130_fd_sc_hd__fill_2
XFILLER_76_249 VGND VGND VPWR VPWR sky130_fd_sc_hd__decap_3
XFILLER_57_452 VGND VGND VPWR VPWR sky130_fd_sc_hd__decap_3
XFILLER_69_290 VGND VGND VPWR VPWR sky130_fd_sc_hd__fill_1
XFILLER_44_102 VGND VGND VPWR VPWR sky130_fd_sc_hd__decap_3
XFILLER_55_33 VGND VGND VPWR VPWR sky130_fd_sc_hd__decap_3
XFILLER_57_485 VGND VGND VPWR VPWR sky130_fd_sc_hd__decap_3
XFILLER_72_400 VGND VGND VPWR VPWR sky130_fd_sc_hd__fill_2
XTAP_TAPCELL_ROW_4_297 VGND VPWR sky130_fd_sc_hd__tapvpwrvgnd_1
XFILLER_45_647 VGND VGND VPWR VPWR sky130_fd_sc_hd__decap_3
XFILLER_72_433 VGND VGND VPWR VPWR sky130_fd_sc_hd__decap_3
XFILLER_13_500 VGND VGND VPWR VPWR sky130_fd_sc_hd__decap_3
XFILLER_44_179 VGND VGND VPWR VPWR sky130_fd_sc_hd__decap_3
XFILLER_60_628 VGND VGND VPWR VPWR sky130_fd_sc_hd__decap_3
XTAP_TAPCELL_ROW_84_1261 VGND VPWR sky130_fd_sc_hd__tapvpwrvgnd_1
XFILLER_111_72 VGND VGND VPWR VPWR sky130_fd_sc_hd__decap_3
XFILLER_13_511 VGND VGND VPWR VPWR sky130_fd_sc_hd__fill_2
XFILLER_13_533 VGND VGND VPWR VPWR sky130_fd_sc_hd__fill_1
XFILLER_25_393 VGND VGND VPWR VPWR sky130_fd_sc_hd__decap_3
XFILLER_71_43 VGND VGND VPWR VPWR sky130_fd_sc_hd__decap_3
XFILLER_71_65 VGND VGND VPWR VPWR sky130_fd_sc_hd__decap_3
XFILLER_40_374 VGND VGND VPWR VPWR sky130_fd_sc_hd__decap_3
XFILLER_71_98 VGND VGND VPWR VPWR sky130_fd_sc_hd__decap_3
XFILLER_9_559 VGND VGND VPWR VPWR sky130_fd_sc_hd__fill_1
XFILLER_114_619 VGND VGND VPWR VPWR sky130_fd_sc_hd__decap_3
XFILLER_99_308 VGND VGND VPWR VPWR sky130_fd_sc_hd__decap_3
XFILLER_107_671 VGND VGND VPWR VPWR sky130_fd_sc_hd__fill_1
XFILLER_107_682 VGND VGND VPWR VPWR sky130_fd_sc_hd__decap_3
XFILLER_4_253 VGND VGND VPWR VPWR sky130_fd_sc_hd__fill_2
XTAP_TAPCELL_ROW_95_1390 VGND VPWR sky130_fd_sc_hd__tapvpwrvgnd_1
XFILLER_67_216 VGND VGND VPWR VPWR sky130_fd_sc_hd__decap_3
XFILLER_95_547 VGND VGND VPWR VPWR sky130_fd_sc_hd__decap_3
XFILLER_96_73 VGND VGND VPWR VPWR sky130_fd_sc_hd__decap_3
XFILLER_48_452 VGND VGND VPWR VPWR sky130_fd_sc_hd__decap_3
XFILLER_48_463 VGND VGND VPWR VPWR sky130_fd_sc_hd__decap_3
XFILLER_35_113 VGND VGND VPWR VPWR sky130_fd_sc_hd__decap_3
XFILLER_35_146 VGND VGND VPWR VPWR sky130_fd_sc_hd__decap_3
XFILLER_75_293 VGND VGND VPWR VPWR sky130_fd_sc_hd__decap_3
XFILLER_90_230 VGND VGND VPWR VPWR sky130_fd_sc_hd__decap_3
Xplace400 _4505_/S VGND VGND VPWR VPWR _4499_/S sky130_fd_sc_hd__buf_2
Xplace411 _4419_/B1 VGND VGND VPWR VPWR _4354_/B1 sky130_fd_sc_hd__buf_2
Xplace422 _3973_/S VGND VGND VPWR VPWR _4471_/S sky130_fd_sc_hd__buf_2
XFILLER_51_617 VGND VGND VPWR VPWR sky130_fd_sc_hd__decap_3
Xplace433 _3366_/X VGND VGND VPWR VPWR _4459_/C1 sky130_fd_sc_hd__buf_2
Xplace444 _4909_/A VGND VGND VPWR VPWR _4960_/A sky130_fd_sc_hd__buf_2
Xplace455 _3371_/A VGND VGND VPWR VPWR _3369_/A sky130_fd_sc_hd__buf_2
XFILLER_16_371 VGND VGND VPWR VPWR sky130_fd_sc_hd__decap_3
XFILLER_50_138 VGND VGND VPWR VPWR sky130_fd_sc_hd__fill_2
XFILLER_91_3 VGND VGND VPWR VPWR sky130_fd_sc_hd__decap_3
X_6670_ _6670_/A VGND VGND VPWR VPWR _6670_/Y sky130_fd_sc_hd__inv_2
X_3882_ _6974_/Q _3889_/A2 _3889_/B1 _6969_/Q _3881_/X VGND VGND VPWR VPWR _3882_/X
+ sky130_fd_sc_hd__a221o_2
XTAP_TAPCELL_ROW_21_509 VGND VPWR sky130_fd_sc_hd__tapvpwrvgnd_1
XFILLER_31_385 VGND VGND VPWR VPWR sky130_fd_sc_hd__decap_3
XFILLER_31_396 VGND VGND VPWR VPWR sky130_fd_sc_hd__decap_3
X_5621_ _5621_/A VGND VGND VPWR VPWR _5622_/A sky130_fd_sc_hd__inv_2
XFILLER_8_581 VGND VGND VPWR VPWR sky130_fd_sc_hd__decap_3
X_4503_ _4503_/A0 _7296_/Q _4503_/S VGND VGND VPWR VPWR _7328_/D sky130_fd_sc_hd__mux2_2
XFILLER_6_71 VGND VGND VPWR VPWR sky130_fd_sc_hd__decap_3
X_7222_ clkload7/A _7222_/D _6502_/Y VGND VGND VPWR VPWR _7222_/Q sky130_fd_sc_hd__dfrtp_2
X_4434_ _7111_/Q _4434_/A2 _4434_/B1 _7143_/Q _4433_/X VGND VGND VPWR VPWR _4434_/X
+ sky130_fd_sc_hd__a221o_2
XFILLER_113_641 VGND VGND VPWR VPWR sky130_fd_sc_hd__decap_3
X_7153_ _7322_/CLK _7153_/D _6433_/Y VGND VGND VPWR VPWR _7153_/Q sky130_fd_sc_hd__dfrtp_2
X_4365_ _4365_/A _4365_/B _4365_/C VGND VGND VPWR VPWR _4365_/X sky130_fd_sc_hd__and3_2
XFILLER_98_330 VGND VGND VPWR VPWR sky130_fd_sc_hd__decap_3
X_7084_ _7267_/CLK _7084_/D _6364_/Y VGND VGND VPWR VPWR _7084_/Q sky130_fd_sc_hd__dfrtp_2
X_3316_ _3365_/A _6983_/Q VGND VGND VPWR VPWR _3332_/B sky130_fd_sc_hd__nor2b_2
XFILLER_98_374 VGND VGND VPWR VPWR sky130_fd_sc_hd__decap_3
XFILLER_98_363 VGND VGND VPWR VPWR sky130_fd_sc_hd__fill_1
XFILLER_112_162 VGND VGND VPWR VPWR sky130_fd_sc_hd__decap_3
XFILLER_112_195 VGND VGND VPWR VPWR sky130_fd_sc_hd__fill_1
XFILLER_58_227 VGND VGND VPWR VPWR sky130_fd_sc_hd__decap_3
XFILLER_86_525 VGND VGND VPWR VPWR sky130_fd_sc_hd__decap_3
XFILLER_86_536 VGND VGND VPWR VPWR sky130_fd_sc_hd__decap_3
X_4296_ _4292_/A _3591_/Y _4295_/X VGND VGND VPWR VPWR _4297_/B sky130_fd_sc_hd__a21oi_2
XFILLER_66_271 VGND VGND VPWR VPWR sky130_fd_sc_hd__decap_3
XTAP_TAPCELL_ROW_1_267 VGND VPWR sky130_fd_sc_hd__tapvpwrvgnd_1
XTAP_TAPCELL_ROW_107_1537 VGND VPWR sky130_fd_sc_hd__tapvpwrvgnd_1
XFILLER_26_168 VGND VGND VPWR VPWR sky130_fd_sc_hd__decap_3
XFILLER_42_628 VGND VGND VPWR VPWR sky130_fd_sc_hd__decap_3
XFILLER_54_488 VGND VGND VPWR VPWR sky130_fd_sc_hd__fill_1
XFILLER_25_47 VGND VGND VPWR VPWR sky130_fd_sc_hd__decap_3
XFILLER_54_499 VGND VGND VPWR VPWR sky130_fd_sc_hd__decap_3
X_6937_ _7005_/CLK _6937_/D VGND VGND VPWR VPWR _6937_/Q sky130_fd_sc_hd__dfxtp_2
XTAP_TAPCELL_ROW_37_697 VGND VPWR sky130_fd_sc_hd__tapvpwrvgnd_1
X_6868_ _6964_/CLK _6868_/D VGND VGND VPWR VPWR _6868_/Q sky130_fd_sc_hd__dfxtp_2
XFILLER_22_374 VGND VGND VPWR VPWR sky130_fd_sc_hd__decap_3
XFILLER_50_672 VGND VGND VPWR VPWR sky130_fd_sc_hd__decap_3
XFILLER_10_547 VGND VGND VPWR VPWR sky130_fd_sc_hd__decap_3
XFILLER_10_569 VGND VGND VPWR VPWR sky130_fd_sc_hd__fill_1
XFILLER_41_35 VGND VGND VPWR VPWR sky130_fd_sc_hd__decap_3
XFILLER_41_57 VGND VGND VPWR VPWR sky130_fd_sc_hd__decap_3
X_6799_ _7230_/CLK _6799_/D VGND VGND VPWR VPWR _6799_/Q sky130_fd_sc_hd__dfxtp_2
XFILLER_108_446 VGND VGND VPWR VPWR sky130_fd_sc_hd__decap_3
XFILLER_104_641 VGND VGND VPWR VPWR sky130_fd_sc_hd__decap_3
XFILLER_1_223 VGND VGND VPWR VPWR sky130_fd_sc_hd__fill_1
XFILLER_89_330 VGND VGND VPWR VPWR sky130_fd_sc_hd__decap_3
Xhold581 _6944_/Q VGND VGND VPWR VPWR _6944_/D sky130_fd_sc_hd__dlygate4sd3_1
XTAP_TAPCELL_ROW_9_356 VGND VPWR sky130_fd_sc_hd__tapvpwrvgnd_1
XFILLER_104_663 VGND VGND VPWR VPWR sky130_fd_sc_hd__decap_3
XFILLER_77_514 VGND VGND VPWR VPWR sky130_fd_sc_hd__decap_3
Xhold592 _6856_/Q VGND VGND VPWR VPWR _6856_/D sky130_fd_sc_hd__dlygate4sd3_1
XFILLER_103_184 VGND VGND VPWR VPWR sky130_fd_sc_hd__decap_3
XFILLER_106_50 VGND VGND VPWR VPWR sky130_fd_sc_hd__decap_3
XFILLER_2_29 VGND VGND VPWR VPWR sky130_fd_sc_hd__decap_3
XFILLER_77_547 VGND VGND VPWR VPWR sky130_fd_sc_hd__decap_3
XFILLER_89_385 VGND VGND VPWR VPWR sky130_fd_sc_hd__decap_3
XFILLER_89_396 VGND VGND VPWR VPWR sky130_fd_sc_hd__decap_3
XFILLER_106_83 VGND VGND VPWR VPWR sky130_fd_sc_hd__fill_1
XFILLER_106_94 VGND VGND VPWR VPWR sky130_fd_sc_hd__fill_1
XFILLER_49_249 VGND VGND VPWR VPWR sky130_fd_sc_hd__decap_3
XFILLER_66_32 VGND VGND VPWR VPWR sky130_fd_sc_hd__fill_2
XFILLER_45_400 VGND VGND VPWR VPWR sky130_fd_sc_hd__decap_3
XFILLER_64_219 VGND VGND VPWR VPWR sky130_fd_sc_hd__decap_3
XFILLER_17_135 VGND VGND VPWR VPWR sky130_fd_sc_hd__decap_3
XFILLER_45_444 VGND VGND VPWR VPWR sky130_fd_sc_hd__decap_3
XFILLER_57_293 VGND VGND VPWR VPWR sky130_fd_sc_hd__decap_3
XFILLER_85_591 VGND VGND VPWR VPWR sky130_fd_sc_hd__decap_3
XFILLER_33_617 VGND VGND VPWR VPWR sky130_fd_sc_hd__fill_2
XFILLER_72_241 VGND VGND VPWR VPWR sky130_fd_sc_hd__decap_3
XFILLER_82_53 VGND VGND VPWR VPWR sky130_fd_sc_hd__decap_3
XFILLER_13_352 VGND VGND VPWR VPWR sky130_fd_sc_hd__fill_2
XFILLER_41_650 VGND VGND VPWR VPWR sky130_fd_sc_hd__decap_3
XFILLER_82_97 VGND VGND VPWR VPWR sky130_fd_sc_hd__decap_3
XFILLER_40_171 VGND VGND VPWR VPWR sky130_fd_sc_hd__decap_3
XFILLER_9_345 VGND VGND VPWR VPWR sky130_fd_sc_hd__fill_2
XFILLER_9_389 VGND VGND VPWR VPWR sky130_fd_sc_hd__decap_3
XFILLER_114_416 VGND VGND VPWR VPWR sky130_fd_sc_hd__decap_3
XFILLER_114_427 VGND VGND VPWR VPWR sky130_fd_sc_hd__fill_2
XFILLER_56_6 VGND VGND VPWR VPWR sky130_fd_sc_hd__decap_3
XFILLER_99_116 VGND VGND VPWR VPWR sky130_fd_sc_hd__decap_3
X_4150_ _7234_/Q _3318_/B _4394_/B _7362_/Q VGND VGND VPWR VPWR _4150_/X sky130_fd_sc_hd__a22o_2
XFILLER_110_622 VGND VGND VPWR VPWR sky130_fd_sc_hd__decap_3
XFILLER_68_536 VGND VGND VPWR VPWR sky130_fd_sc_hd__decap_3
XFILLER_110_666 VGND VGND VPWR VPWR sky130_fd_sc_hd__decap_3
XFILLER_68_569 VGND VGND VPWR VPWR sky130_fd_sc_hd__decap_3
XFILLER_95_366 VGND VGND VPWR VPWR sky130_fd_sc_hd__decap_3
X_4081_ _4451_/A _4451_/B VGND VGND VPWR VPWR _4081_/X sky130_fd_sc_hd__or2b_2
XFILLER_48_271 VGND VGND VPWR VPWR sky130_fd_sc_hd__decap_3
XFILLER_83_528 VGND VGND VPWR VPWR sky130_fd_sc_hd__decap_3
XFILLER_36_477 VGND VGND VPWR VPWR sky130_fd_sc_hd__decap_3
XFILLER_91_561 VGND VGND VPWR VPWR sky130_fd_sc_hd__decap_3
XFILLER_23_116 VGND VGND VPWR VPWR sky130_fd_sc_hd__decap_3
XFILLER_23_138 VGND VGND VPWR VPWR sky130_fd_sc_hd__decap_3
XFILLER_51_414 VGND VGND VPWR VPWR sky130_fd_sc_hd__decap_3
XFILLER_51_447 VGND VGND VPWR VPWR sky130_fd_sc_hd__fill_1
Xplace263 _5658_/D VGND VGND VPWR VPWR _5117_/B sky130_fd_sc_hd__buf_2
X_4983_ _5015_/A _4983_/B _4983_/C VGND VGND VPWR VPWR _4983_/X sky130_fd_sc_hd__and3_2
Xplace296 _3926_/B1 VGND VGND VPWR VPWR _3862_/B1 sky130_fd_sc_hd__buf_2
Xplace285 _3906_/B1 VGND VGND VPWR VPWR _3913_/B1 sky130_fd_sc_hd__buf_2
Xplace274 _3886_/A2 VGND VGND VPWR VPWR _3906_/A2 sky130_fd_sc_hd__buf_2
X_6722_ _6972_/CLK _6722_/D VGND VGND VPWR VPWR _6722_/Q sky130_fd_sc_hd__dfxtp_2
XTAP_TAPCELL_ROW_34_656 VGND VPWR sky130_fd_sc_hd__tapvpwrvgnd_1
XFILLER_32_672 VGND VGND VPWR VPWR sky130_fd_sc_hd__decap_3
X_6653_ _6683_/A VGND VGND VPWR VPWR _6653_/Y sky130_fd_sc_hd__inv_2
XTAP_TAPCELL_ROW_62_998 VGND VPWR sky130_fd_sc_hd__tapvpwrvgnd_1
XTAP_TAPCELL_ROW_102_1478 VGND VPWR sky130_fd_sc_hd__tapvpwrvgnd_1
XFILLER_31_193 VGND VGND VPWR VPWR sky130_fd_sc_hd__decap_3
X_6584_ _6584_/A VGND VGND VPWR VPWR _6584_/Y sky130_fd_sc_hd__inv_2
X_3796_ _6726_/Q _3879_/A2 _3889_/A2 _6976_/Q _3795_/X VGND VGND VPWR VPWR _3796_/X
+ sky130_fd_sc_hd__a221o_2
XFILLER_11_27 VGND VGND VPWR VPWR sky130_fd_sc_hd__decap_3
XFILLER_105_405 VGND VGND VPWR VPWR sky130_fd_sc_hd__decap_3
XFILLER_105_438 VGND VGND VPWR VPWR sky130_fd_sc_hd__decap_3
X_7205_ _7368_/CLK _7205_/D _6485_/Y VGND VGND VPWR VPWR _7205_/Q sky130_fd_sc_hd__dfrtp_2
X_4417_ _7304_/Q _4865_/S _4434_/A2 _7112_/Q _4416_/X VGND VGND VPWR VPWR _4417_/X
+ sky130_fd_sc_hd__a221o_2
XFILLER_101_600 VGND VGND VPWR VPWR sky130_fd_sc_hd__decap_3
XTAP_TAPCELL_ROW_6_326 VGND VPWR sky130_fd_sc_hd__tapvpwrvgnd_1
XFILLER_113_482 VGND VGND VPWR VPWR sky130_fd_sc_hd__fill_1
XFILLER_59_514 VGND VGND VPWR VPWR sky130_fd_sc_hd__fill_1
X_7136_ _7397_/CLK _7136_/D _6416_/Y VGND VGND VPWR VPWR _7136_/Q sky130_fd_sc_hd__dfrtp_2
X_4348_ _7161_/Q _3366_/X _4348_/B1 _7129_/Q _4347_/X VGND VGND VPWR VPWR _4348_/X
+ sky130_fd_sc_hd__a221o_2
XFILLER_100_121 VGND VGND VPWR VPWR sky130_fd_sc_hd__decap_3
XFILLER_101_666 VGND VGND VPWR VPWR sky130_fd_sc_hd__decap_3
XFILLER_59_569 VGND VGND VPWR VPWR sky130_fd_sc_hd__fill_1
X_7067_ clkload9/A _7067_/D _6347_/Y VGND VGND VPWR VPWR _7067_/Q sky130_fd_sc_hd__dfrtp_2
X_4279_ _7318_/Q _3977_/S wire566/X _7126_/Q VGND VGND VPWR VPWR _4279_/X sky130_fd_sc_hd__a22o_2
XFILLER_100_165 VGND VGND VPWR VPWR sky130_fd_sc_hd__decap_3
XFILLER_101_688 VGND VGND VPWR VPWR sky130_fd_sc_hd__decap_3
XFILLER_27_411 VGND VGND VPWR VPWR sky130_fd_sc_hd__decap_3
XFILLER_67_580 VGND VGND VPWR VPWR sky130_fd_sc_hd__decap_3
XFILLER_74_539 VGND VGND VPWR VPWR sky130_fd_sc_hd__decap_3
XFILLER_86_377 VGND VGND VPWR VPWR sky130_fd_sc_hd__decap_3
XFILLER_36_24 VGND VGND VPWR VPWR sky130_fd_sc_hd__decap_3
XFILLER_36_46 VGND VGND VPWR VPWR sky130_fd_sc_hd__decap_3
XFILLER_39_293 VGND VGND VPWR VPWR sky130_fd_sc_hd__decap_3
XFILLER_27_455 VGND VGND VPWR VPWR sky130_fd_sc_hd__decap_3
XFILLER_36_79 VGND VGND VPWR VPWR sky130_fd_sc_hd__decap_3
XTAP_TAPCELL_ROW_68_1064 VGND VPWR sky130_fd_sc_hd__tapvpwrvgnd_1
XFILLER_54_274 VGND VGND VPWR VPWR sky130_fd_sc_hd__decap_3
XFILLER_82_583 VGND VGND VPWR VPWR sky130_fd_sc_hd__decap_3
XFILLER_14_138 VGND VGND VPWR VPWR sky130_fd_sc_hd__fill_2
XFILLER_42_469 VGND VGND VPWR VPWR sky130_fd_sc_hd__decap_3
XTAP_TAPCELL_ROW_81_1220 VGND VPWR sky130_fd_sc_hd__tapvpwrvgnd_1
XFILLER_10_300 VGND VGND VPWR VPWR sky130_fd_sc_hd__decap_3
XFILLER_22_193 VGND VGND VPWR VPWR sky130_fd_sc_hd__decap_3
XFILLER_52_67 VGND VGND VPWR VPWR sky130_fd_sc_hd__decap_3
XFILLER_10_377 VGND VGND VPWR VPWR sky130_fd_sc_hd__decap_3
XFILLER_6_315 VGND VGND VPWR VPWR sky130_fd_sc_hd__decap_3
XFILLER_108_298 VGND VGND VPWR VPWR sky130_fd_sc_hd__fill_1
XTAP_TAPCELL_ROW_92_1360 VGND VPWR sky130_fd_sc_hd__tapvpwrvgnd_1
XFILLER_77_300 VGND VGND VPWR VPWR sky130_fd_sc_hd__decap_3
XFILLER_77_42 VGND VGND VPWR VPWR sky130_fd_sc_hd__decap_3
XFILLER_77_86 VGND VGND VPWR VPWR sky130_fd_sc_hd__decap_3
XFILLER_37_208 VGND VGND VPWR VPWR sky130_fd_sc_hd__decap_3
XFILLER_77_388 VGND VGND VPWR VPWR sky130_fd_sc_hd__fill_1
XFILLER_77_399 VGND VGND VPWR VPWR sky130_fd_sc_hd__fill_2
XFILLER_93_30 VGND VGND VPWR VPWR sky130_fd_sc_hd__decap_3
XFILLER_18_455 VGND VGND VPWR VPWR sky130_fd_sc_hd__decap_3
XFILLER_18_477 VGND VGND VPWR VPWR sky130_fd_sc_hd__decap_3
XFILLER_45_252 VGND VGND VPWR VPWR sky130_fd_sc_hd__decap_3
XFILLER_80_509 VGND VGND VPWR VPWR sky130_fd_sc_hd__decap_3
XFILLER_93_63 VGND VGND VPWR VPWR sky130_fd_sc_hd__decap_3
XFILLER_33_447 VGND VGND VPWR VPWR sky130_fd_sc_hd__fill_1
XFILLER_60_244 VGND VGND VPWR VPWR sky130_fd_sc_hd__decap_3
XFILLER_14_683 VGND VGND VPWR VPWR sky130_fd_sc_hd__fill_1
XTAP_TAPCELL_ROW_31_626 VGND VPWR sky130_fd_sc_hd__tapvpwrvgnd_1
XFILLER_13_193 VGND VGND VPWR VPWR sky130_fd_sc_hd__decap_3
XFILLER_60_299 VGND VGND VPWR VPWR sky130_fd_sc_hd__fill_2
XFILLER_9_142 VGND VGND VPWR VPWR sky130_fd_sc_hd__decap_3
X_3650_ _3991_/B VGND VGND VPWR VPWR _3665_/A sky130_fd_sc_hd__inv_2
XFILLER_9_175 VGND VGND VPWR VPWR sky130_fd_sc_hd__fill_1
X_3581_ _7156_/Q _3409_/X _3579_/X _3580_/X VGND VGND VPWR VPWR _3583_/B sky130_fd_sc_hd__a211o_2
XTAP_TAPCELL_ROW_11_383 VGND VPWR sky130_fd_sc_hd__tapvpwrvgnd_1
XFILLER_54_3 VGND VGND VPWR VPWR sky130_fd_sc_hd__decap_3
XFILLER_114_224 VGND VGND VPWR VPWR sky130_fd_sc_hd__decap_3
XFILLER_5_381 VGND VGND VPWR VPWR sky130_fd_sc_hd__fill_2
X_5251_ _5251_/A0 _4899_/X _5262_/S VGND VGND VPWR VPWR _7204_/D sky130_fd_sc_hd__mux2_2
X_4202_ _4202_/A VGND VGND VPWR VPWR _4203_/C sky130_fd_sc_hd__inv_2
XFILLER_68_322 VGND VGND VPWR VPWR sky130_fd_sc_hd__decap_3
XFILLER_87_119 VGND VGND VPWR VPWR sky130_fd_sc_hd__fill_1
X_5182_ _5182_/A _5182_/B VGND VGND VPWR VPWR _7237_/D sky130_fd_sc_hd__and2_2
XFILLER_3_72 VGND VGND VPWR VPWR sky130_fd_sc_hd__decap_3
XFILLER_68_355 VGND VGND VPWR VPWR sky130_fd_sc_hd__decap_3
XFILLER_95_141 VGND VGND VPWR VPWR sky130_fd_sc_hd__decap_3
XFILLER_96_653 VGND VGND VPWR VPWR sky130_fd_sc_hd__decap_3
X_4133_ _7363_/Q _4394_/B _4267_/B1 _7171_/Q VGND VGND VPWR VPWR _4133_/X sky130_fd_sc_hd__a22o_2
XFILLER_110_474 VGND VGND VPWR VPWR sky130_fd_sc_hd__fill_2
XFILLER_113_18 VGND VGND VPWR VPWR sky130_fd_sc_hd__decap_3
XFILLER_68_377 VGND VGND VPWR VPWR sky130_fd_sc_hd__decap_3
XFILLER_83_314 VGND VGND VPWR VPWR sky130_fd_sc_hd__decap_3
XFILLER_96_686 VGND VGND VPWR VPWR sky130_fd_sc_hd__decap_3
X_4064_ _7372_/Q _4435_/B1 _4772_/S _7308_/Q _4063_/X VGND VGND VPWR VPWR _4064_/X
+ sky130_fd_sc_hd__a221o_2
XTAP_TAPCELL_ROW_39_715 VGND VPWR sky130_fd_sc_hd__tapvpwrvgnd_1
XFILLER_95_196 VGND VGND VPWR VPWR sky130_fd_sc_hd__decap_3
XTAP_TAPCELL_ROW_19_483 VGND VPWR sky130_fd_sc_hd__tapvpwrvgnd_1
XFILLER_12_609 VGND VGND VPWR VPWR sky130_fd_sc_hd__decap_3
XFILLER_24_469 VGND VGND VPWR VPWR sky130_fd_sc_hd__decap_3
XFILLER_11_108 VGND VGND VPWR VPWR sky130_fd_sc_hd__decap_3
XFILLER_11_119 VGND VGND VPWR VPWR sky130_fd_sc_hd__decap_3
X_6705_ _7230_/CLK _6705_/D VGND VGND VPWR VPWR _6705_/Q sky130_fd_sc_hd__dfxtp_2
XFILLER_22_15 VGND VGND VPWR VPWR sky130_fd_sc_hd__decap_3
XFILLER_32_480 VGND VGND VPWR VPWR sky130_fd_sc_hd__fill_1
XFILLER_51_299 VGND VGND VPWR VPWR sky130_fd_sc_hd__fill_2
X_4897_ _4896_/A _4896_/B _4896_/Y _4777_/A VGND VGND VPWR VPWR _4897_/X sky130_fd_sc_hd__o211a_2
X_3917_ _6689_/Q _3925_/A2 _3917_/B1 _6867_/Q VGND VGND VPWR VPWR _3917_/X sky130_fd_sc_hd__a22o_2
X_6636_ _6637_/A VGND VGND VPWR VPWR _6636_/Y sky130_fd_sc_hd__inv_2
X_3848_ _6907_/Q _3906_/A2 _3906_/B1 _6851_/Q VGND VGND VPWR VPWR _3848_/X sky130_fd_sc_hd__a22o_2
XFILLER_22_59 VGND VGND VPWR VPWR sky130_fd_sc_hd__decap_3
X_6567_ _6567_/A VGND VGND VPWR VPWR _6567_/Y sky130_fd_sc_hd__inv_2
X_3779_ _6794_/Q _3926_/B1 _3906_/B1 _6704_/Q _3778_/X VGND VGND VPWR VPWR _3779_/X
+ sky130_fd_sc_hd__a221o_2
XFILLER_3_318 VGND VGND VPWR VPWR sky130_fd_sc_hd__decap_3
XTAP_TAPCELL_ROW_115_1636 VGND VPWR sky130_fd_sc_hd__tapvpwrvgnd_1
XFILLER_105_213 VGND VGND VPWR VPWR sky130_fd_sc_hd__decap_3
X_6498_ _6635_/A VGND VGND VPWR VPWR _6498_/Y sky130_fd_sc_hd__inv_2
XFILLER_78_108 VGND VGND VPWR VPWR sky130_fd_sc_hd__decap_3
Xoutput461 _5650_/Y VGND VGND VPWR VPWR alu_result_out[0] sky130_fd_sc_hd__clkdlybuf4s25_1
XFILLER_59_311 VGND VGND VPWR VPWR sky130_fd_sc_hd__decap_3
XFILLER_87_620 VGND VGND VPWR VPWR sky130_fd_sc_hd__decap_3
Xoutput494 _5647_/Y VGND VGND VPWR VPWR instruction_out[11] sky130_fd_sc_hd__clkdlybuf4s25_1
Xoutput483 _3991_/B VGND VGND VPWR VPWR alu_result_out[2] sky130_fd_sc_hd__clkdlybuf4s25_1
Xoutput472 _5659_/B VGND VGND VPWR VPWR alu_result_out[1] sky130_fd_sc_hd__clkdlybuf4s25_1
XFILLER_99_480 VGND VGND VPWR VPWR sky130_fd_sc_hd__decap_3
XFILLER_101_441 VGND VGND VPWR VPWR sky130_fd_sc_hd__decap_3
XFILLER_113_290 VGND VGND VPWR VPWR sky130_fd_sc_hd__decap_3
XFILLER_59_355 VGND VGND VPWR VPWR sky130_fd_sc_hd__fill_1
XFILLER_86_130 VGND VGND VPWR VPWR sky130_fd_sc_hd__decap_3
XFILLER_86_141 VGND VGND VPWR VPWR sky130_fd_sc_hd__decap_3
X_7119_ _7322_/CLK _7119_/D _6399_/Y VGND VGND VPWR VPWR _7119_/Q sky130_fd_sc_hd__dfrtp_2
XFILLER_101_452 VGND VGND VPWR VPWR sky130_fd_sc_hd__fill_2
XFILLER_19_219 VGND VGND VPWR VPWR sky130_fd_sc_hd__decap_3
XFILLER_59_366 VGND VGND VPWR VPWR sky130_fd_sc_hd__decap_3
XFILLER_74_303 VGND VGND VPWR VPWR sky130_fd_sc_hd__decap_3
XFILLER_47_78 VGND VGND VPWR VPWR sky130_fd_sc_hd__decap_3
XFILLER_59_399 VGND VGND VPWR VPWR sky130_fd_sc_hd__fill_2
XFILLER_86_185 VGND VGND VPWR VPWR sky130_fd_sc_hd__decap_3
XFILLER_103_51 VGND VGND VPWR VPWR sky130_fd_sc_hd__decap_3
XFILLER_55_561 VGND VGND VPWR VPWR sky130_fd_sc_hd__decap_3
XFILLER_103_84 VGND VGND VPWR VPWR sky130_fd_sc_hd__decap_3
XFILLER_27_263 VGND VGND VPWR VPWR sky130_fd_sc_hd__decap_3
XFILLER_42_200 VGND VGND VPWR VPWR sky130_fd_sc_hd__decap_3
XFILLER_82_380 VGND VGND VPWR VPWR sky130_fd_sc_hd__decap_3
XFILLER_42_233 VGND VGND VPWR VPWR sky130_fd_sc_hd__decap_3
XFILLER_63_44 VGND VGND VPWR VPWR sky130_fd_sc_hd__decap_3
XFILLER_70_597 VGND VGND VPWR VPWR sky130_fd_sc_hd__decap_3
XFILLER_8_17 VGND VGND VPWR VPWR sky130_fd_sc_hd__decap_3
XFILLER_6_112 VGND VGND VPWR VPWR sky130_fd_sc_hd__decap_3
Xwire566 _3378_/Y VGND VGND VPWR VPWR wire566/X sky130_fd_sc_hd__clkbuf_4
XFILLER_6_156 VGND VGND VPWR VPWR sky130_fd_sc_hd__decap_3
XFILLER_7_668 VGND VGND VPWR VPWR sky130_fd_sc_hd__decap_3
XFILLER_7_679 VGND VGND VPWR VPWR sky130_fd_sc_hd__decap_3
XFILLER_40_9 VGND VGND VPWR VPWR sky130_fd_sc_hd__decap_3
XFILLER_2_362 VGND VGND VPWR VPWR sky130_fd_sc_hd__fill_2
XFILLER_88_85 VGND VGND VPWR VPWR sky130_fd_sc_hd__decap_3
XFILLER_104_290 VGND VGND VPWR VPWR sky130_fd_sc_hd__decap_3
XFILLER_2_395 VGND VGND VPWR VPWR sky130_fd_sc_hd__decap_3
XFILLER_78_664 VGND VGND VPWR VPWR sky130_fd_sc_hd__decap_3
XFILLER_65_314 VGND VGND VPWR VPWR sky130_fd_sc_hd__decap_3
XFILLER_77_196 VGND VGND VPWR VPWR sky130_fd_sc_hd__decap_3
XFILLER_93_656 VGND VGND VPWR VPWR sky130_fd_sc_hd__decap_3
XFILLER_18_230 VGND VGND VPWR VPWR sky130_fd_sc_hd__decap_3
XFILLER_65_358 VGND VGND VPWR VPWR sky130_fd_sc_hd__decap_3
XFILLER_92_144 VGND VGND VPWR VPWR sky130_fd_sc_hd__decap_3
XFILLER_92_166 VGND VGND VPWR VPWR sky130_fd_sc_hd__fill_2
XFILLER_33_211 VGND VGND VPWR VPWR sky130_fd_sc_hd__decap_3
XFILLER_80_317 VGND VGND VPWR VPWR sky130_fd_sc_hd__decap_3
X_4820_ _4836_/S _5634_/B VGND VGND VPWR VPWR _5010_/A sky130_fd_sc_hd__nand2_2
XTAP_TAPCELL_ROW_16_442 VGND VPWR sky130_fd_sc_hd__tapvpwrvgnd_1
XFILLER_33_266 VGND VGND VPWR VPWR sky130_fd_sc_hd__decap_3
XFILLER_61_564 VGND VGND VPWR VPWR sky130_fd_sc_hd__decap_3
XTAP_TAPCELL_ROW_44_784 VGND VPWR sky130_fd_sc_hd__tapvpwrvgnd_1
XFILLER_14_480 VGND VGND VPWR VPWR sky130_fd_sc_hd__fill_2
X_4751_ _4751_/A _4751_/B VGND VGND VPWR VPWR _4751_/Y sky130_fd_sc_hd__nand2_2
X_4682_ _4928_/B _4682_/B _4960_/B VGND VGND VPWR VPWR _4943_/A sky130_fd_sc_hd__and3b_2
X_3702_ hold981/X _4832_/A _3701_/X VGND VGND VPWR VPWR _7401_/D sky130_fd_sc_hd__o21a_2
X_6421_ _6483_/A VGND VGND VPWR VPWR _6421_/Y sky130_fd_sc_hd__inv_2
X_3633_ _3636_/A _5072_/A _3635_/B _3630_/A VGND VGND VPWR VPWR _3633_/Y sky130_fd_sc_hd__a22oi_2
XFILLER_108_18 VGND VGND VPWR VPWR sky130_fd_sc_hd__decap_3
XFILLER_108_29 VGND VGND VPWR VPWR sky130_fd_sc_hd__decap_3
XFILLER_115_533 VGND VGND VPWR VPWR sky130_fd_sc_hd__decap_3
XFILLER_6_690 VGND VGND VPWR VPWR sky130_fd_sc_hd__fill_2
X_6352_ _6388_/A VGND VGND VPWR VPWR _6352_/Y sky130_fd_sc_hd__inv_2
X_3564_ _5118_/A _5362_/C VGND VGND VPWR VPWR _3564_/X sky130_fd_sc_hd__and2_2
XFILLER_88_406 VGND VGND VPWR VPWR sky130_fd_sc_hd__decap_3
X_6283_ _6285_/A VGND VGND VPWR VPWR _6283_/Y sky130_fd_sc_hd__inv_2
X_3495_ _7028_/Q _4503_/S _3494_/X VGND VGND VPWR VPWR _3495_/X sky130_fd_sc_hd__a21o_2
XFILLER_115_588 VGND VGND VPWR VPWR sky130_fd_sc_hd__decap_3
XFILLER_88_439 VGND VGND VPWR VPWR sky130_fd_sc_hd__decap_3
X_5234_ _5234_/A0 _4734_/X _5245_/S VGND VGND VPWR VPWR _7213_/D sky130_fd_sc_hd__mux2_2
XFILLER_68_130 VGND VGND VPWR VPWR sky130_fd_sc_hd__decap_3
X_5165_ _5165_/A _5182_/B VGND VGND VPWR VPWR _7245_/D sky130_fd_sc_hd__and2_2
XTAP_TAPCELL_ROW_110_1566 VGND VPWR sky130_fd_sc_hd__tapvpwrvgnd_1
XFILLER_68_141 VGND VGND VPWR VPWR sky130_fd_sc_hd__decap_3
XFILLER_84_601 VGND VGND VPWR VPWR sky130_fd_sc_hd__decap_3
XFILLER_96_472 VGND VGND VPWR VPWR sky130_fd_sc_hd__decap_3
X_4116_ _7076_/Q _4265_/B VGND VGND VPWR VPWR _4117_/C sky130_fd_sc_hd__or2_2
XTAP_TAPCELL_ROW_110_1577 VGND VPWR sky130_fd_sc_hd__tapvpwrvgnd_1
XFILLER_68_174 VGND VGND VPWR VPWR sky130_fd_sc_hd__decap_3
XFILLER_83_122 VGND VGND VPWR VPWR sky130_fd_sc_hd__decap_3
XFILLER_96_483 VGND VGND VPWR VPWR sky130_fd_sc_hd__decap_3
XFILLER_17_15 VGND VGND VPWR VPWR sky130_fd_sc_hd__decap_3
XFILLER_37_561 VGND VGND VPWR VPWR sky130_fd_sc_hd__decap_3
XFILLER_83_155 VGND VGND VPWR VPWR sky130_fd_sc_hd__decap_3
X_4047_ _7245_/Q _4433_/B _4437_/A2 _7027_/Q _4046_/X VGND VGND VPWR VPWR _4047_/X
+ sky130_fd_sc_hd__a221o_2
XFILLER_17_48 VGND VGND VPWR VPWR sky130_fd_sc_hd__decap_3
XFILLER_64_380 VGND VGND VPWR VPWR sky130_fd_sc_hd__fill_1
XTAP_TAPCELL_ROW_65_1034 VGND VPWR sky130_fd_sc_hd__tapvpwrvgnd_1
XFILLER_12_406 VGND VGND VPWR VPWR sky130_fd_sc_hd__fill_1
XFILLER_24_277 VGND VGND VPWR VPWR sky130_fd_sc_hd__decap_3
X_4949_ _4967_/A _4967_/B VGND VGND VPWR VPWR _4949_/Y sky130_fd_sc_hd__nand2_2
X_6619_ _6619_/A VGND VGND VPWR VPWR _6619_/Y sky130_fd_sc_hd__inv_2
XFILLER_106_500 VGND VGND VPWR VPWR sky130_fd_sc_hd__fill_2
XFILLER_4_638 VGND VGND VPWR VPWR sky130_fd_sc_hd__decap_3
XFILLER_3_137 VGND VGND VPWR VPWR sky130_fd_sc_hd__decap_3
XTAP_TAPCELL_ROW_76_1163 VGND VPWR sky130_fd_sc_hd__tapvpwrvgnd_1
XFILLER_58_22 VGND VGND VPWR VPWR sky130_fd_sc_hd__decap_3
XFILLER_79_417 VGND VGND VPWR VPWR sky130_fd_sc_hd__decap_3
XFILLER_58_44 VGND VGND VPWR VPWR sky130_fd_sc_hd__decap_3
XFILLER_58_66 VGND VGND VPWR VPWR sky130_fd_sc_hd__decap_3
XFILLER_58_88 VGND VGND VPWR VPWR sky130_fd_sc_hd__decap_3
XFILLER_59_141 VGND VGND VPWR VPWR sky130_fd_sc_hd__decap_3
XFILLER_101_293 VGND VGND VPWR VPWR sky130_fd_sc_hd__decap_3
XFILLER_114_50 VGND VGND VPWR VPWR sky130_fd_sc_hd__decap_3
XFILLER_59_196 VGND VGND VPWR VPWR sky130_fd_sc_hd__decap_3
XFILLER_74_111 VGND VGND VPWR VPWR sky130_fd_sc_hd__decap_3
XFILLER_75_623 VGND VGND VPWR VPWR sky130_fd_sc_hd__decap_3
XFILLER_114_83 VGND VGND VPWR VPWR sky130_fd_sc_hd__fill_1
XFILLER_114_94 VGND VGND VPWR VPWR sky130_fd_sc_hd__decap_3
XFILLER_47_369 VGND VGND VPWR VPWR sky130_fd_sc_hd__decap_3
XFILLER_62_306 VGND VGND VPWR VPWR sky130_fd_sc_hd__fill_2
XFILLER_74_144 VGND VGND VPWR VPWR sky130_fd_sc_hd__decap_3
XFILLER_74_155 VGND VGND VPWR VPWR sky130_fd_sc_hd__decap_3
XFILLER_74_32 VGND VGND VPWR VPWR sky130_fd_sc_hd__decap_3
XFILLER_15_211 VGND VGND VPWR VPWR sky130_fd_sc_hd__decap_3
XFILLER_62_317 VGND VGND VPWR VPWR sky130_fd_sc_hd__decap_3
XFILLER_74_76 VGND VGND VPWR VPWR sky130_fd_sc_hd__decap_3
XTAP_TAPCELL_ROW_87_1292 VGND VPWR sky130_fd_sc_hd__tapvpwrvgnd_1
XFILLER_15_255 VGND VGND VPWR VPWR sky130_fd_sc_hd__decap_3
XFILLER_30_203 VGND VGND VPWR VPWR sky130_fd_sc_hd__decap_3
XFILLER_43_564 VGND VGND VPWR VPWR sky130_fd_sc_hd__decap_3
XFILLER_70_361 VGND VGND VPWR VPWR sky130_fd_sc_hd__decap_3
XFILLER_90_20 VGND VGND VPWR VPWR sky130_fd_sc_hd__decap_3
XFILLER_15_299 VGND VGND VPWR VPWR sky130_fd_sc_hd__decap_3
XFILLER_43_597 VGND VGND VPWR VPWR sky130_fd_sc_hd__fill_2
XTAP_TAPCELL_ROW_13_412 VGND VPWR sky130_fd_sc_hd__tapvpwrvgnd_1
XFILLER_88_9 VGND VGND VPWR VPWR sky130_fd_sc_hd__decap_3
XFILLER_90_97 VGND VGND VPWR VPWR sky130_fd_sc_hd__decap_3
XTAP_TAPCELL_ROW_41_743 VGND VPWR sky130_fd_sc_hd__tapvpwrvgnd_1
XFILLER_23_91 VGND VGND VPWR VPWR sky130_fd_sc_hd__decap_3
XFILLER_7_498 VGND VGND VPWR VPWR sky130_fd_sc_hd__fill_2
XFILLER_99_51 VGND VGND VPWR VPWR sky130_fd_sc_hd__decap_3
XFILLER_99_84 VGND VGND VPWR VPWR sky130_fd_sc_hd__decap_3
XFILLER_3_671 VGND VGND VPWR VPWR sky130_fd_sc_hd__fill_1
XFILLER_3_682 VGND VGND VPWR VPWR sky130_fd_sc_hd__fill_2
XFILLER_97_225 VGND VGND VPWR VPWR sky130_fd_sc_hd__decap_3
XFILLER_112_536 VGND VGND VPWR VPWR sky130_fd_sc_hd__decap_3
XFILLER_2_181 VGND VGND VPWR VPWR sky130_fd_sc_hd__fill_1
XFILLER_97_258 VGND VGND VPWR VPWR sky130_fd_sc_hd__decap_3
XFILLER_17_3 VGND VGND VPWR VPWR sky130_fd_sc_hd__decap_3
XFILLER_65_122 VGND VGND VPWR VPWR sky130_fd_sc_hd__decap_3
XFILLER_66_634 VGND VGND VPWR VPWR sky130_fd_sc_hd__decap_3
XFILLER_66_645 VGND VGND VPWR VPWR sky130_fd_sc_hd__decap_3
XFILLER_78_483 VGND VGND VPWR VPWR sky130_fd_sc_hd__decap_3
XTAP_TAPCELL_ROW_49_843 VGND VPWR sky130_fd_sc_hd__tapvpwrvgnd_1
XFILLER_65_144 VGND VGND VPWR VPWR sky130_fd_sc_hd__decap_3
XFILLER_66_678 VGND VGND VPWR VPWR sky130_fd_sc_hd__decap_3
XFILLER_93_464 VGND VGND VPWR VPWR sky130_fd_sc_hd__decap_3
X_6970_ _6977_/CLK _6970_/D VGND VGND VPWR VPWR _6970_/Q sky130_fd_sc_hd__dfxtp_2
XFILLER_19_561 VGND VGND VPWR VPWR sky130_fd_sc_hd__fill_1
XFILLER_65_199 VGND VGND VPWR VPWR sky130_fd_sc_hd__decap_3
XFILLER_81_626 VGND VGND VPWR VPWR sky130_fd_sc_hd__decap_3
XFILLER_0_95 VGND VGND VPWR VPWR sky130_fd_sc_hd__decap_3
XFILLER_80_136 VGND VGND VPWR VPWR sky130_fd_sc_hd__decap_3
XFILLER_80_147 VGND VGND VPWR VPWR sky130_fd_sc_hd__decap_3
XFILLER_21_214 VGND VGND VPWR VPWR sky130_fd_sc_hd__fill_2
XFILLER_21_225 VGND VGND VPWR VPWR sky130_fd_sc_hd__decap_3
XFILLER_34_597 VGND VGND VPWR VPWR sky130_fd_sc_hd__decap_3
X_4803_ _7003_/Q _4802_/X _4677_/B _3403_/A VGND VGND VPWR VPWR _4804_/B sky130_fd_sc_hd__o211ai_2
XFILLER_21_258 VGND VGND VPWR VPWR sky130_fd_sc_hd__fill_2
X_4734_ _4726_/X _4729_/Y _7007_/D _4836_/S VGND VGND VPWR VPWR _4734_/X sky130_fd_sc_hd__o22a_2
XFILLER_9_60 VGND VGND VPWR VPWR sky130_fd_sc_hd__decap_3
XFILLER_9_93 VGND VGND VPWR VPWR sky130_fd_sc_hd__fill_2
XFILLER_107_319 VGND VGND VPWR VPWR sky130_fd_sc_hd__decap_3
X_4665_ _7005_/Q _5605_/B VGND VGND VPWR VPWR _4665_/X sky130_fd_sc_hd__or2_2
X_7384_ _7384_/CLK _7384_/D _6664_/Y VGND VGND VPWR VPWR _7384_/Q sky130_fd_sc_hd__dfrtp_2
Xhold900 _7109_/Q VGND VGND VPWR VPWR _7109_/D sky130_fd_sc_hd__dlygate4sd3_1
Xhold911 _5674_/X VGND VGND VPWR VPWR _6687_/D sky130_fd_sc_hd__dlygate4sd3_1
Xhold922 _6693_/Q VGND VGND VPWR VPWR hold922/X sky130_fd_sc_hd__dlygate4sd3_1
X_6404_ _6567_/A VGND VGND VPWR VPWR _6404_/Y sky130_fd_sc_hd__inv_2
X_3616_ _4614_/C _3616_/B VGND VGND VPWR VPWR _3616_/Y sky130_fd_sc_hd__nand2_2
XFILLER_115_352 VGND VGND VPWR VPWR sky130_fd_sc_hd__fill_2
Xhold933 _6717_/Q VGND VGND VPWR VPWR hold933/X sky130_fd_sc_hd__dlygate4sd3_1
Xhold955 _7036_/Q VGND VGND VPWR VPWR hold955/X sky130_fd_sc_hd__dlygate4sd3_1
Xhold944 _7041_/Q VGND VGND VPWR VPWR hold944/X sky130_fd_sc_hd__dlygate4sd3_1
X_6335_ _6568_/A VGND VGND VPWR VPWR _6335_/Y sky130_fd_sc_hd__inv_2
X_3547_ _3547_/A _3547_/B VGND VGND VPWR VPWR _3547_/Y sky130_fd_sc_hd__nand2_2
XFILLER_0_107 VGND VGND VPWR VPWR sky130_fd_sc_hd__decap_3
XFILLER_103_503 VGND VGND VPWR VPWR sky130_fd_sc_hd__fill_1
XFILLER_103_514 VGND VGND VPWR VPWR sky130_fd_sc_hd__decap_3
XFILLER_88_203 VGND VGND VPWR VPWR sky130_fd_sc_hd__decap_3
Xhold988 _7051_/Q VGND VGND VPWR VPWR hold988/X sky130_fd_sc_hd__dlygate4sd3_1
Xhold977 _7379_/Q VGND VGND VPWR VPWR hold977/X sky130_fd_sc_hd__dlygate4sd3_1
Xhold966 _7035_/Q VGND VGND VPWR VPWR hold966/X sky130_fd_sc_hd__dlygate4sd3_1
XFILLER_0_129 VGND VGND VPWR VPWR sky130_fd_sc_hd__decap_3
XFILLER_115_396 VGND VGND VPWR VPWR sky130_fd_sc_hd__fill_1
Xhold999 _7397_/Q VGND VGND VPWR VPWR hold999/X sky130_fd_sc_hd__dlygate4sd3_1
X_6266_ _6522_/A VGND VGND VPWR VPWR _6266_/Y sky130_fd_sc_hd__inv_2
X_3478_ _7216_/Q _4331_/A2 _4534_/S _7029_/Q _3477_/X VGND VGND VPWR VPWR _3478_/X
+ sky130_fd_sc_hd__a221o_2
XFILLER_69_472 VGND VGND VPWR VPWR sky130_fd_sc_hd__decap_3
X_5217_ _5217_/A _5217_/B VGND VGND VPWR VPWR _7220_/D sky130_fd_sc_hd__and2_2
XFILLER_111_591 VGND VGND VPWR VPWR sky130_fd_sc_hd__decap_3
XFILLER_57_623 VGND VGND VPWR VPWR sky130_fd_sc_hd__decap_3
X_5148_ _5144_/A _5071_/A _3618_/C _3540_/X VGND VGND VPWR VPWR _5148_/X sky130_fd_sc_hd__a211o_2
XFILLER_28_69 VGND VGND VPWR VPWR sky130_fd_sc_hd__fill_1
XFILLER_56_144 VGND VGND VPWR VPWR sky130_fd_sc_hd__decap_3
XFILLER_57_656 VGND VGND VPWR VPWR sky130_fd_sc_hd__decap_3
XFILLER_84_442 VGND VGND VPWR VPWR sky130_fd_sc_hd__decap_3
X_5079_ _5156_/S _6987_/D _5078_/X VGND VGND VPWR VPWR _5079_/X sky130_fd_sc_hd__o21a_2
XFILLER_44_339 VGND VGND VPWR VPWR sky130_fd_sc_hd__decap_3
XFILLER_56_166 VGND VGND VPWR VPWR sky130_fd_sc_hd__decap_3
XFILLER_37_391 VGND VGND VPWR VPWR sky130_fd_sc_hd__fill_1
XFILLER_44_24 VGND VGND VPWR VPWR sky130_fd_sc_hd__decap_3
XFILLER_12_203 VGND VGND VPWR VPWR sky130_fd_sc_hd__decap_3
XFILLER_12_236 VGND VGND VPWR VPWR sky130_fd_sc_hd__decap_3
XFILLER_25_597 VGND VGND VPWR VPWR sky130_fd_sc_hd__decap_3
XFILLER_80_681 VGND VGND VPWR VPWR sky130_fd_sc_hd__decap_3
XFILLER_100_41 VGND VGND VPWR VPWR sky130_fd_sc_hd__decap_3
XFILLER_12_247 VGND VGND VPWR VPWR sky130_fd_sc_hd__decap_3
XFILLER_100_74 VGND VGND VPWR VPWR sky130_fd_sc_hd__decap_3
XFILLER_100_85 VGND VGND VPWR VPWR sky130_fd_sc_hd__decap_3
XFILLER_40_589 VGND VGND VPWR VPWR sky130_fd_sc_hd__decap_3
XFILLER_60_23 VGND VGND VPWR VPWR sky130_fd_sc_hd__decap_3
XFILLER_4_424 VGND VGND VPWR VPWR sky130_fd_sc_hd__decap_3
XFILLER_5_18 VGND VGND VPWR VPWR sky130_fd_sc_hd__decap_3
XFILLER_106_330 VGND VGND VPWR VPWR sky130_fd_sc_hd__decap_3
XFILLER_109_72 VGND VGND VPWR VPWR sky130_fd_sc_hd__decap_3
XFILLER_4_446 VGND VGND VPWR VPWR sky130_fd_sc_hd__decap_3
XFILLER_69_21 VGND VGND VPWR VPWR sky130_fd_sc_hd__decap_3
XFILLER_106_374 VGND VGND VPWR VPWR sky130_fd_sc_hd__decap_3
XFILLER_69_54 VGND VGND VPWR VPWR sky130_fd_sc_hd__fill_2
XFILLER_79_214 VGND VGND VPWR VPWR sky130_fd_sc_hd__fill_2
XFILLER_0_641 VGND VGND VPWR VPWR sky130_fd_sc_hd__decap_3
XFILLER_48_612 VGND VGND VPWR VPWR sky130_fd_sc_hd__decap_3
XFILLER_48_645 VGND VGND VPWR VPWR sky130_fd_sc_hd__decap_3
XFILLER_75_420 VGND VGND VPWR VPWR sky130_fd_sc_hd__decap_3
XTAP_TAPCELL_ROW_89_1321 VGND VPWR sky130_fd_sc_hd__tapvpwrvgnd_1
XFILLER_48_678 VGND VGND VPWR VPWR sky130_fd_sc_hd__decap_3
XFILLER_75_464 VGND VGND VPWR VPWR sky130_fd_sc_hd__decap_3
XFILLER_85_64 VGND VGND VPWR VPWR sky130_fd_sc_hd__decap_3
XFILLER_62_103 VGND VGND VPWR VPWR sky130_fd_sc_hd__fill_2
XFILLER_63_626 VGND VGND VPWR VPWR sky130_fd_sc_hd__decap_3
XFILLER_75_497 VGND VGND VPWR VPWR sky130_fd_sc_hd__decap_3
XTAP_TAPCELL_ROW_46_802 VGND VPWR sky130_fd_sc_hd__tapvpwrvgnd_1
XFILLER_16_531 VGND VGND VPWR VPWR sky130_fd_sc_hd__fill_1
XFILLER_18_91 VGND VGND VPWR VPWR sky130_fd_sc_hd__decap_3
XFILLER_62_147 VGND VGND VPWR VPWR sky130_fd_sc_hd__decap_3
XFILLER_63_659 VGND VGND VPWR VPWR sky130_fd_sc_hd__decap_3
XFILLER_50_309 VGND VGND VPWR VPWR sky130_fd_sc_hd__decap_3
XFILLER_62_169 VGND VGND VPWR VPWR sky130_fd_sc_hd__decap_3
XFILLER_16_586 VGND VGND VPWR VPWR sky130_fd_sc_hd__fill_2
XFILLER_16_597 VGND VGND VPWR VPWR sky130_fd_sc_hd__decap_3
XFILLER_43_383 VGND VGND VPWR VPWR sky130_fd_sc_hd__decap_3
XFILLER_31_556 VGND VGND VPWR VPWR sky130_fd_sc_hd__decap_3
XFILLER_31_578 VGND VGND VPWR VPWR sky130_fd_sc_hd__decap_3
XFILLER_86_6 VGND VGND VPWR VPWR sky130_fd_sc_hd__decap_3
XFILLER_7_240 VGND VGND VPWR VPWR sky130_fd_sc_hd__decap_3
XFILLER_116_116 VGND VGND VPWR VPWR sky130_fd_sc_hd__fill_2
XFILLER_7_284 VGND VGND VPWR VPWR sky130_fd_sc_hd__decap_3
X_4450_ _4451_/A _4451_/B VGND VGND VPWR VPWR _4452_/A sky130_fd_sc_hd__and2_2
XFILLER_116_138 VGND VGND VPWR VPWR sky130_fd_sc_hd__fill_2
XFILLER_7_295 VGND VGND VPWR VPWR sky130_fd_sc_hd__decap_3
X_4381_ _4381_/A _4381_/B VGND VGND VPWR VPWR _4967_/B sky130_fd_sc_hd__nand2_2
X_3401_ _4467_/A _3519_/B _5294_/A _3330_/Y VGND VGND VPWR VPWR _3401_/X sky130_fd_sc_hd__a31o_4
XFILLER_112_300 VGND VGND VPWR VPWR sky130_fd_sc_hd__decap_3
X_3332_ _4467_/A _3332_/B VGND VGND VPWR VPWR _3341_/A sky130_fd_sc_hd__nand2_2
XFILLER_98_523 VGND VGND VPWR VPWR sky130_fd_sc_hd__fill_2
XFILLER_98_512 VGND VGND VPWR VPWR sky130_fd_sc_hd__fill_2
XFILLER_112_355 VGND VGND VPWR VPWR sky130_fd_sc_hd__decap_3
XFILLER_98_589 VGND VGND VPWR VPWR sky130_fd_sc_hd__fill_1
XFILLER_98_567 VGND VGND VPWR VPWR sky130_fd_sc_hd__decap_3
XFILLER_100_528 VGND VGND VPWR VPWR sky130_fd_sc_hd__decap_3
XFILLER_39_634 VGND VGND VPWR VPWR sky130_fd_sc_hd__fill_2
X_5002_ _5003_/A _5003_/B _3548_/X VGND VGND VPWR VPWR _5002_/Y sky130_fd_sc_hd__a21oi_2
XFILLER_38_133 VGND VGND VPWR VPWR sky130_fd_sc_hd__fill_2
XFILLER_38_144 VGND VGND VPWR VPWR sky130_fd_sc_hd__decap_3
XFILLER_39_656 VGND VGND VPWR VPWR sky130_fd_sc_hd__decap_3
XFILLER_54_604 VGND VGND VPWR VPWR sky130_fd_sc_hd__decap_3
XFILLER_78_291 VGND VGND VPWR VPWR sky130_fd_sc_hd__decap_3
XFILLER_38_177 VGND VGND VPWR VPWR sky130_fd_sc_hd__decap_3
XFILLER_53_103 VGND VGND VPWR VPWR sky130_fd_sc_hd__decap_3
XFILLER_54_637 VGND VGND VPWR VPWR sky130_fd_sc_hd__decap_3
XFILLER_66_486 VGND VGND VPWR VPWR sky130_fd_sc_hd__fill_1
XFILLER_19_380 VGND VGND VPWR VPWR sky130_fd_sc_hd__decap_3
XFILLER_26_339 VGND VGND VPWR VPWR sky130_fd_sc_hd__decap_3
XFILLER_54_648 VGND VGND VPWR VPWR sky130_fd_sc_hd__decap_3
XFILLER_81_445 VGND VGND VPWR VPWR sky130_fd_sc_hd__decap_3
XFILLER_93_294 VGND VGND VPWR VPWR sky130_fd_sc_hd__fill_2
X_6953_ _6965_/CLK _6953_/D VGND VGND VPWR VPWR _6953_/Q sky130_fd_sc_hd__dfxtp_2
XFILLER_34_361 VGND VGND VPWR VPWR sky130_fd_sc_hd__decap_3
XFILLER_53_169 VGND VGND VPWR VPWR sky130_fd_sc_hd__decap_3
XFILLER_81_467 VGND VGND VPWR VPWR sky130_fd_sc_hd__decap_3
Xclkbuf_3_5__f_clk clkbuf_0_clk/X VGND VGND VPWR VPWR clkload2/A sky130_fd_sc_hd__clkbuf_16
X_6884_ _7392_/CLK _6884_/D VGND VGND VPWR VPWR _6884_/Q sky130_fd_sc_hd__dfxtp_2
XFILLER_14_27 VGND VGND VPWR VPWR sky130_fd_sc_hd__fill_1
XFILLER_22_512 VGND VGND VPWR VPWR sky130_fd_sc_hd__decap_3
XFILLER_62_681 VGND VGND VPWR VPWR sky130_fd_sc_hd__decap_3
XFILLER_14_38 VGND VGND VPWR VPWR sky130_fd_sc_hd__decap_3
XFILLER_22_545 VGND VGND VPWR VPWR sky130_fd_sc_hd__fill_1
XFILLER_22_578 VGND VGND VPWR VPWR sky130_fd_sc_hd__fill_1
X_5697_ _7354_/Q hold913/X _5719_/S VGND VGND VPWR VPWR _6698_/D sky130_fd_sc_hd__mux2_2
XFILLER_107_116 VGND VGND VPWR VPWR sky130_fd_sc_hd__decap_3
XFILLER_108_628 VGND VGND VPWR VPWR sky130_fd_sc_hd__decap_3
XFILLER_30_26 VGND VGND VPWR VPWR sky130_fd_sc_hd__fill_2
X_4648_ _4648_/A VGND VGND VPWR VPWR _4648_/Y sky130_fd_sc_hd__inv_2
Xhold730 _6943_/Q VGND VGND VPWR VPWR _6943_/D sky130_fd_sc_hd__dlygate4sd3_1
XFILLER_1_405 VGND VGND VPWR VPWR sky130_fd_sc_hd__decap_3
X_7367_ _7369_/CLK _7367_/D _6647_/Y VGND VGND VPWR VPWR _7367_/Q sky130_fd_sc_hd__dfrtp_2
Xhold741 _6815_/Q VGND VGND VPWR VPWR _6815_/D sky130_fd_sc_hd__dlygate4sd3_1
Xhold752 _6776_/Q VGND VGND VPWR VPWR _6776_/D sky130_fd_sc_hd__dlygate4sd3_1
Xhold763 _6877_/Q VGND VGND VPWR VPWR _6877_/D sky130_fd_sc_hd__dlygate4sd3_1
X_4579_ _7291_/Q _4595_/B VGND VGND VPWR VPWR _7291_/D sky130_fd_sc_hd__and2_2
XTAP_TAPCELL_ROW_73_1122 VGND VPWR sky130_fd_sc_hd__tapvpwrvgnd_1
XFILLER_103_322 VGND VGND VPWR VPWR sky130_fd_sc_hd__decap_3
XFILLER_115_193 VGND VGND VPWR VPWR sky130_fd_sc_hd__decap_3
XFILLER_1_449 VGND VGND VPWR VPWR sky130_fd_sc_hd__decap_3
X_7298_ _7363_/CLK _7298_/D _6578_/Y VGND VGND VPWR VPWR _7298_/Q sky130_fd_sc_hd__dfrtp_2
Xhold774 _6893_/Q VGND VGND VPWR VPWR _6893_/D sky130_fd_sc_hd__dlygate4sd3_1
Xhold785 _6812_/Q VGND VGND VPWR VPWR _6812_/D sky130_fd_sc_hd__dlygate4sd3_1
Xhold796 _6935_/Q VGND VGND VPWR VPWR _6935_/D sky130_fd_sc_hd__dlygate4sd3_1
X_6318_ _6674_/A VGND VGND VPWR VPWR _6318_/Y sky130_fd_sc_hd__inv_2
XTAP_TAPCELL_ROW_73_1133 VGND VPWR sky130_fd_sc_hd__tapvpwrvgnd_1
XFILLER_103_377 VGND VGND VPWR VPWR sky130_fd_sc_hd__decap_3
XFILLER_39_46 VGND VGND VPWR VPWR sky130_fd_sc_hd__decap_3
XFILLER_89_567 VGND VGND VPWR VPWR sky130_fd_sc_hd__fill_2
XFILLER_29_122 VGND VGND VPWR VPWR sky130_fd_sc_hd__decap_3
XFILLER_57_442 VGND VGND VPWR VPWR sky130_fd_sc_hd__decap_3
XFILLER_17_317 VGND VGND VPWR VPWR sky130_fd_sc_hd__decap_3
XFILLER_45_615 VGND VGND VPWR VPWR sky130_fd_sc_hd__fill_1
XFILLER_45_626 VGND VGND VPWR VPWR sky130_fd_sc_hd__decap_3
XFILLER_55_12 VGND VGND VPWR VPWR sky130_fd_sc_hd__decap_3
XFILLER_84_250 VGND VGND VPWR VPWR sky130_fd_sc_hd__fill_2
XTAP_TAPCELL_ROW_4_298 VGND VPWR sky130_fd_sc_hd__tapvpwrvgnd_1
XFILLER_29_199 VGND VGND VPWR VPWR sky130_fd_sc_hd__decap_3
XFILLER_45_659 VGND VGND VPWR VPWR sky130_fd_sc_hd__decap_3
XFILLER_55_45 VGND VGND VPWR VPWR sky130_fd_sc_hd__decap_3
XFILLER_55_78 VGND VGND VPWR VPWR sky130_fd_sc_hd__decap_3
XFILLER_84_294 VGND VGND VPWR VPWR sky130_fd_sc_hd__fill_2
XFILLER_111_40 VGND VGND VPWR VPWR sky130_fd_sc_hd__decap_3
XFILLER_25_361 VGND VGND VPWR VPWR sky130_fd_sc_hd__decap_3
XFILLER_32_309 VGND VGND VPWR VPWR sky130_fd_sc_hd__fill_2
XFILLER_53_670 VGND VGND VPWR VPWR sky130_fd_sc_hd__fill_2
XFILLER_60_607 VGND VGND VPWR VPWR sky130_fd_sc_hd__decap_3
XFILLER_52_180 VGND VGND VPWR VPWR sky130_fd_sc_hd__decap_3
XFILLER_71_22 VGND VGND VPWR VPWR sky130_fd_sc_hd__decap_3
XTAP_TAPCELL_ROW_84_1262 VGND VPWR sky130_fd_sc_hd__tapvpwrvgnd_1
XFILLER_111_84 VGND VGND VPWR VPWR sky130_fd_sc_hd__decap_3
XFILLER_13_545 VGND VGND VPWR VPWR sky130_fd_sc_hd__decap_3
XFILLER_40_353 VGND VGND VPWR VPWR sky130_fd_sc_hd__fill_1
XFILLER_71_55 VGND VGND VPWR VPWR sky130_fd_sc_hd__fill_1
XFILLER_9_505 VGND VGND VPWR VPWR sky130_fd_sc_hd__fill_2
XFILLER_40_386 VGND VGND VPWR VPWR sky130_fd_sc_hd__decap_3
XTAP_TAPCELL_ROW_51_860 VGND VPWR sky130_fd_sc_hd__tapvpwrvgnd_1
XFILLER_107_650 VGND VGND VPWR VPWR sky130_fd_sc_hd__decap_3
XFILLER_4_221 VGND VGND VPWR VPWR sky130_fd_sc_hd__fill_1
XFILLER_106_160 VGND VGND VPWR VPWR sky130_fd_sc_hd__decap_3
XFILLER_113_108 VGND VGND VPWR VPWR sky130_fd_sc_hd__decap_3
XFILLER_113_119 VGND VGND VPWR VPWR sky130_fd_sc_hd__decap_3
XFILLER_4_243 VGND VGND VPWR VPWR sky130_fd_sc_hd__decap_3
XTAP_TAPCELL_ROW_95_1391 VGND VPWR sky130_fd_sc_hd__tapvpwrvgnd_1
XFILLER_106_182 VGND VGND VPWR VPWR sky130_fd_sc_hd__decap_3
XFILLER_96_41 VGND VGND VPWR VPWR sky130_fd_sc_hd__decap_3
XFILLER_67_228 VGND VGND VPWR VPWR sky130_fd_sc_hd__decap_3
XFILLER_96_85 VGND VGND VPWR VPWR sky130_fd_sc_hd__decap_3
XFILLER_48_431 VGND VGND VPWR VPWR sky130_fd_sc_hd__decap_3
XFILLER_29_90 VGND VGND VPWR VPWR sky130_fd_sc_hd__fill_1
XFILLER_35_103 VGND VGND VPWR VPWR sky130_fd_sc_hd__fill_2
XFILLER_48_475 VGND VGND VPWR VPWR sky130_fd_sc_hd__fill_1
XFILLER_82_209 VGND VGND VPWR VPWR sky130_fd_sc_hd__decap_3
XTAP_TAPCELL_ROW_59_960 VGND VPWR sky130_fd_sc_hd__tapvpwrvgnd_1
XFILLER_63_445 VGND VGND VPWR VPWR sky130_fd_sc_hd__decap_3
Xplace401 _4505_/S VGND VGND VPWR VPWR _4478_/S sky130_fd_sc_hd__buf_2
Xplace412 _4332_/B1 VGND VGND VPWR VPWR _4338_/B1 sky130_fd_sc_hd__buf_2
XFILLER_35_158 VGND VGND VPWR VPWR sky130_fd_sc_hd__decap_3
XFILLER_35_169 VGND VGND VPWR VPWR sky130_fd_sc_hd__decap_3
XFILLER_50_106 VGND VGND VPWR VPWR sky130_fd_sc_hd__decap_3
XFILLER_51_607 VGND VGND VPWR VPWR sky130_fd_sc_hd__decap_3
XFILLER_51_629 VGND VGND VPWR VPWR sky130_fd_sc_hd__decap_3
XFILLER_63_489 VGND VGND VPWR VPWR sky130_fd_sc_hd__fill_2
XFILLER_90_242 VGND VGND VPWR VPWR sky130_fd_sc_hd__decap_3
XFILLER_90_253 VGND VGND VPWR VPWR sky130_fd_sc_hd__decap_3
Xplace423 _3979_/S VGND VGND VPWR VPWR _3989_/S sky130_fd_sc_hd__buf_2
Xplace434 _3366_/X VGND VGND VPWR VPWR _4339_/B1 sky130_fd_sc_hd__buf_2
Xplace445 _5647_/A VGND VGND VPWR VPWR _4909_/A sky130_fd_sc_hd__buf_2
Xplace456 _6981_/Q VGND VGND VPWR VPWR _3371_/A sky130_fd_sc_hd__buf_2
XFILLER_16_383 VGND VGND VPWR VPWR sky130_fd_sc_hd__fill_2
XFILLER_44_681 VGND VGND VPWR VPWR sky130_fd_sc_hd__decap_3
X_3881_ _6724_/Q _3884_/A2 _3912_/B1 _6719_/Q VGND VGND VPWR VPWR _3881_/X sky130_fd_sc_hd__a22o_2
XFILLER_31_375 VGND VGND VPWR VPWR sky130_fd_sc_hd__fill_1
XFILLER_84_3 VGND VGND VPWR VPWR sky130_fd_sc_hd__decap_3
XFILLER_6_50 VGND VGND VPWR VPWR sky130_fd_sc_hd__decap_3
X_7221_ clkload5/A _7221_/D _6501_/Y VGND VGND VPWR VPWR _7221_/Q sky130_fd_sc_hd__dfrtp_2
XFILLER_6_83 VGND VGND VPWR VPWR sky130_fd_sc_hd__fill_1
XFILLER_6_94 VGND VGND VPWR VPWR sky130_fd_sc_hd__decap_3
X_4433_ _7239_/Q _4433_/B VGND VGND VPWR VPWR _4433_/X sky130_fd_sc_hd__and2_2
XFILLER_113_620 VGND VGND VPWR VPWR sky130_fd_sc_hd__decap_3
XFILLER_116_29 VGND VGND VPWR VPWR sky130_fd_sc_hd__decap_3
X_7152_ _7356_/CLK _7152_/D _6432_/Y VGND VGND VPWR VPWR _7152_/Q sky130_fd_sc_hd__dfrtp_2
X_4364_ _4364_/A _4364_/B VGND VGND VPWR VPWR _4364_/Y sky130_fd_sc_hd__nor2_2
XFILLER_98_320 VGND VGND VPWR VPWR sky130_fd_sc_hd__decap_3
XFILLER_112_130 VGND VGND VPWR VPWR sky130_fd_sc_hd__decap_3
XFILLER_112_141 VGND VGND VPWR VPWR sky130_fd_sc_hd__decap_3
XFILLER_113_653 VGND VGND VPWR VPWR sky130_fd_sc_hd__decap_3
XFILLER_58_206 VGND VGND VPWR VPWR sky130_fd_sc_hd__decap_3
X_7083_ _7267_/CLK _7083_/D _6363_/Y VGND VGND VPWR VPWR _7083_/Q sky130_fd_sc_hd__dfrtp_2
X_4295_ _3607_/B _4295_/B VGND VGND VPWR VPWR _4295_/X sky130_fd_sc_hd__and2b_2
XFILLER_98_342 VGND VGND VPWR VPWR sky130_fd_sc_hd__decap_3
XFILLER_112_174 VGND VGND VPWR VPWR sky130_fd_sc_hd__decap_3
XFILLER_98_386 VGND VGND VPWR VPWR sky130_fd_sc_hd__decap_3
XFILLER_26_103 VGND VGND VPWR VPWR sky130_fd_sc_hd__fill_1
XFILLER_54_401 VGND VGND VPWR VPWR sky130_fd_sc_hd__decap_3
XFILLER_94_581 VGND VGND VPWR VPWR sky130_fd_sc_hd__decap_3
XFILLER_27_637 VGND VGND VPWR VPWR sky130_fd_sc_hd__decap_3
XFILLER_39_497 VGND VGND VPWR VPWR sky130_fd_sc_hd__decap_3
XFILLER_66_283 VGND VGND VPWR VPWR sky130_fd_sc_hd__decap_3
XTAP_TAPCELL_ROW_107_1538 VGND VPWR sky130_fd_sc_hd__tapvpwrvgnd_1
XFILLER_14_309 VGND VGND VPWR VPWR sky130_fd_sc_hd__decap_3
X_6936_ _6965_/CLK _6936_/D VGND VGND VPWR VPWR _6936_/Q sky130_fd_sc_hd__dfxtp_2
XTAP_TAPCELL_ROW_1_268 VGND VPWR sky130_fd_sc_hd__tapvpwrvgnd_1
XFILLER_35_670 VGND VGND VPWR VPWR sky130_fd_sc_hd__fill_2
XFILLER_41_128 VGND VGND VPWR VPWR sky130_fd_sc_hd__fill_1
XTAP_TAPCELL_ROW_37_698 VGND VPWR sky130_fd_sc_hd__tapvpwrvgnd_1
XFILLER_34_180 VGND VGND VPWR VPWR sky130_fd_sc_hd__decap_3
XFILLER_50_651 VGND VGND VPWR VPWR sky130_fd_sc_hd__decap_3
X_6867_ _7384_/CLK _6867_/D VGND VGND VPWR VPWR _6867_/Q sky130_fd_sc_hd__dfxtp_2
XFILLER_10_504 VGND VGND VPWR VPWR sky130_fd_sc_hd__decap_3
XFILLER_41_14 VGND VGND VPWR VPWR sky130_fd_sc_hd__decap_3
XFILLER_50_684 VGND VGND VPWR VPWR sky130_fd_sc_hd__decap_3
X_6798_ _7406_/CLK _6798_/D VGND VGND VPWR VPWR _6798_/Q sky130_fd_sc_hd__dfxtp_2
XFILLER_10_559 VGND VGND VPWR VPWR sky130_fd_sc_hd__fill_1
XFILLER_41_47 VGND VGND VPWR VPWR sky130_fd_sc_hd__decap_3
XFILLER_116_480 VGND VGND VPWR VPWR sky130_fd_sc_hd__decap_3
XTAP_TAPCELL_ROW_9_357 VGND VPWR sky130_fd_sc_hd__tapvpwrvgnd_1
XFILLER_103_141 VGND VGND VPWR VPWR sky130_fd_sc_hd__decap_3
XFILLER_104_675 VGND VGND VPWR VPWR sky130_fd_sc_hd__decap_3
XFILLER_1_246 VGND VGND VPWR VPWR sky130_fd_sc_hd__decap_3
Xhold582 _6874_/Q VGND VGND VPWR VPWR _6874_/D sky130_fd_sc_hd__dlygate4sd3_1
Xhold593 _6808_/Q VGND VGND VPWR VPWR _6808_/D sky130_fd_sc_hd__dlygate4sd3_1
XFILLER_106_62 VGND VGND VPWR VPWR sky130_fd_sc_hd__decap_3
XFILLER_49_228 VGND VGND VPWR VPWR sky130_fd_sc_hd__decap_3
XFILLER_77_526 VGND VGND VPWR VPWR sky130_fd_sc_hd__decap_3
XFILLER_77_559 VGND VGND VPWR VPWR sky130_fd_sc_hd__fill_1
XFILLER_92_507 VGND VGND VPWR VPWR sky130_fd_sc_hd__decap_3
XFILLER_18_626 VGND VGND VPWR VPWR sky130_fd_sc_hd__decap_3
XFILLER_66_66 VGND VGND VPWR VPWR sky130_fd_sc_hd__decap_3
XFILLER_85_570 VGND VGND VPWR VPWR sky130_fd_sc_hd__decap_3
XFILLER_92_529 VGND VGND VPWR VPWR sky130_fd_sc_hd__decap_3
XFILLER_18_648 VGND VGND VPWR VPWR sky130_fd_sc_hd__decap_3
XFILLER_72_220 VGND VGND VPWR VPWR sky130_fd_sc_hd__decap_3
XFILLER_17_147 VGND VGND VPWR VPWR sky130_fd_sc_hd__decap_3
XFILLER_17_169 VGND VGND VPWR VPWR sky130_fd_sc_hd__decap_3
XFILLER_72_253 VGND VGND VPWR VPWR sky130_fd_sc_hd__fill_1
XFILLER_82_32 VGND VGND VPWR VPWR sky130_fd_sc_hd__decap_3
XFILLER_26_670 VGND VGND VPWR VPWR sky130_fd_sc_hd__fill_2
XFILLER_26_681 VGND VGND VPWR VPWR sky130_fd_sc_hd__decap_3
XFILLER_72_286 VGND VGND VPWR VPWR sky130_fd_sc_hd__decap_3
XFILLER_82_65 VGND VGND VPWR VPWR sky130_fd_sc_hd__decap_3
XFILLER_25_191 VGND VGND VPWR VPWR sky130_fd_sc_hd__decap_3
XFILLER_32_139 VGND VGND VPWR VPWR sky130_fd_sc_hd__fill_1
XFILLER_13_386 VGND VGND VPWR VPWR sky130_fd_sc_hd__decap_3
XFILLER_15_81 VGND VGND VPWR VPWR sky130_fd_sc_hd__decap_3
XFILLER_41_662 VGND VGND VPWR VPWR sky130_fd_sc_hd__decap_3
XFILLER_41_673 VGND VGND VPWR VPWR sky130_fd_sc_hd__decap_3
XFILLER_9_324 VGND VGND VPWR VPWR sky130_fd_sc_hd__decap_3
XFILLER_40_183 VGND VGND VPWR VPWR sky130_fd_sc_hd__decap_3
XFILLER_70_9 VGND VGND VPWR VPWR sky130_fd_sc_hd__decap_3
XTAP_TAPCELL_ROW_97_1420 VGND VPWR sky130_fd_sc_hd__tapvpwrvgnd_1
XFILLER_31_80 VGND VGND VPWR VPWR sky130_fd_sc_hd__decap_3
XFILLER_49_6 VGND VGND VPWR VPWR sky130_fd_sc_hd__decap_3
XFILLER_110_601 VGND VGND VPWR VPWR sky130_fd_sc_hd__decap_3
XFILLER_110_634 VGND VGND VPWR VPWR sky130_fd_sc_hd__decap_3
XFILLER_110_645 VGND VGND VPWR VPWR sky130_fd_sc_hd__decap_3
X_4080_ _4075_/X _4079_/X _4425_/A VGND VGND VPWR VPWR _4451_/B sky130_fd_sc_hd__o21ai_2
XFILLER_110_678 VGND VGND VPWR VPWR sky130_fd_sc_hd__decap_3
XFILLER_95_378 VGND VGND VPWR VPWR sky130_fd_sc_hd__decap_3
XFILLER_48_283 VGND VGND VPWR VPWR sky130_fd_sc_hd__decap_3
XFILLER_48_294 VGND VGND VPWR VPWR sky130_fd_sc_hd__decap_3
XFILLER_91_573 VGND VGND VPWR VPWR sky130_fd_sc_hd__decap_3
XFILLER_24_629 VGND VGND VPWR VPWR sky130_fd_sc_hd__decap_3
XFILLER_51_426 VGND VGND VPWR VPWR sky130_fd_sc_hd__decap_3
XFILLER_63_275 VGND VGND VPWR VPWR sky130_fd_sc_hd__decap_3
Xplace264 _3923_/A1 VGND VGND VPWR VPWR _3682_/A sky130_fd_sc_hd__buf_2
X_4982_ _6992_/Q _4982_/B _5009_/A VGND VGND VPWR VPWR _4983_/C sky130_fd_sc_hd__or3_2
Xplace297 _3886_/B1 VGND VGND VPWR VPWR _3926_/B1 sky130_fd_sc_hd__buf_2
Xplace286 _3893_/B1 VGND VGND VPWR VPWR _3906_/B1 sky130_fd_sc_hd__buf_2
Xplace275 _3661_/X VGND VGND VPWR VPWR _3886_/A2 sky130_fd_sc_hd__buf_2
X_6721_ _6976_/CLK _6721_/D VGND VGND VPWR VPWR _6721_/Q sky130_fd_sc_hd__dfxtp_2
X_3933_ _7373_/Q _4476_/A0 _3947_/S VGND VGND VPWR VPWR _7373_/D sky130_fd_sc_hd__mux2_2
XTAP_TAPCELL_ROW_34_657 VGND VPWR sky130_fd_sc_hd__tapvpwrvgnd_1
XFILLER_31_161 VGND VGND VPWR VPWR sky130_fd_sc_hd__decap_3
XFILLER_32_684 VGND VGND VPWR VPWR sky130_fd_sc_hd__decap_3
X_6652_ _6652_/A VGND VGND VPWR VPWR _6652_/Y sky130_fd_sc_hd__inv_2
X_3864_ _3864_/A0 _3863_/X _5151_/A VGND VGND VPWR VPWR _7385_/D sky130_fd_sc_hd__mux2_2
XTAP_TAPCELL_ROW_62_999 VGND VPWR sky130_fd_sc_hd__tapvpwrvgnd_1
XTAP_TAPCELL_ROW_102_1479 VGND VPWR sky130_fd_sc_hd__tapvpwrvgnd_1
X_6583_ _6587_/A VGND VGND VPWR VPWR _6583_/Y sky130_fd_sc_hd__inv_2
X_3795_ _6971_/Q _3878_/A2 _3878_/B1 _6721_/Q VGND VGND VPWR VPWR _3795_/X sky130_fd_sc_hd__a22o_2
XFILLER_11_39 VGND VGND VPWR VPWR sky130_fd_sc_hd__decap_3
XFILLER_105_417 VGND VGND VPWR VPWR sky130_fd_sc_hd__decap_3
X_7204_ _7365_/CLK _7204_/D _6484_/Y VGND VGND VPWR VPWR _7204_/Q sky130_fd_sc_hd__dfrtp_2
X_4416_ _7368_/Q _4435_/B1 _4436_/B1 _7176_/Q _4415_/X VGND VGND VPWR VPWR _4416_/X
+ sky130_fd_sc_hd__a221o_2
X_7135_ _7264_/CLK _7135_/D _6415_/Y VGND VGND VPWR VPWR _7135_/Q sky130_fd_sc_hd__dfrtp_2
X_5396_ _5396_/A0 _4978_/X _5396_/S VGND VGND VPWR VPWR _7135_/D sky130_fd_sc_hd__mux2_2
XFILLER_99_673 VGND VGND VPWR VPWR sky130_fd_sc_hd__decap_3
XFILLER_99_662 VGND VGND VPWR VPWR sky130_fd_sc_hd__decap_3
XFILLER_100_100 VGND VGND VPWR VPWR sky130_fd_sc_hd__fill_2
XFILLER_101_612 VGND VGND VPWR VPWR sky130_fd_sc_hd__decap_3
XFILLER_101_623 VGND VGND VPWR VPWR sky130_fd_sc_hd__fill_1
XFILLER_113_461 VGND VGND VPWR VPWR sky130_fd_sc_hd__decap_3
XFILLER_59_526 VGND VGND VPWR VPWR sky130_fd_sc_hd__fill_2
XFILLER_86_312 VGND VGND VPWR VPWR sky130_fd_sc_hd__fill_2
XFILLER_86_323 VGND VGND VPWR VPWR sky130_fd_sc_hd__decap_3
X_4347_ _7289_/Q _4517_/S _4346_/X _4248_/A VGND VGND VPWR VPWR _4347_/X sky130_fd_sc_hd__a211o_2
XTAP_TAPCELL_ROW_6_327 VGND VPWR sky130_fd_sc_hd__tapvpwrvgnd_1
XFILLER_100_133 VGND VGND VPWR VPWR sky130_fd_sc_hd__decap_3
XFILLER_101_645 VGND VGND VPWR VPWR sky130_fd_sc_hd__decap_3
XFILLER_59_559 VGND VGND VPWR VPWR sky130_fd_sc_hd__fill_1
X_7066_ clkload9/A _7066_/D _6346_/Y VGND VGND VPWR VPWR _7066_/Q sky130_fd_sc_hd__dfrtp_2
X_4278_ _7286_/Q _4530_/S _4338_/B1 _7350_/Q _3556_/A VGND VGND VPWR VPWR _4278_/X
+ sky130_fd_sc_hd__a221o_2
XFILLER_100_144 VGND VGND VPWR VPWR sky130_fd_sc_hd__decap_3
XFILLER_100_177 VGND VGND VPWR VPWR sky130_fd_sc_hd__decap_3
XFILLER_39_261 VGND VGND VPWR VPWR sky130_fd_sc_hd__decap_3
XFILLER_46_209 VGND VGND VPWR VPWR sky130_fd_sc_hd__fill_1
XFILLER_74_518 VGND VGND VPWR VPWR sky130_fd_sc_hd__decap_3
XFILLER_67_592 VGND VGND VPWR VPWR sky130_fd_sc_hd__decap_3
XFILLER_27_445 VGND VGND VPWR VPWR sky130_fd_sc_hd__decap_3
XFILLER_36_58 VGND VGND VPWR VPWR sky130_fd_sc_hd__decap_3
XFILLER_54_231 VGND VGND VPWR VPWR sky130_fd_sc_hd__fill_1
XFILLER_82_551 VGND VGND VPWR VPWR sky130_fd_sc_hd__decap_3
XTAP_TAPCELL_ROW_68_1065 VGND VPWR sky130_fd_sc_hd__tapvpwrvgnd_1
XFILLER_42_437 VGND VGND VPWR VPWR sky130_fd_sc_hd__decap_3
XFILLER_54_286 VGND VGND VPWR VPWR sky130_fd_sc_hd__decap_3
XFILLER_52_24 VGND VGND VPWR VPWR sky130_fd_sc_hd__decap_3
X_6919_ _7387_/CLK _6919_/D VGND VGND VPWR VPWR _6919_/Q sky130_fd_sc_hd__dfxtp_2
XTAP_TAPCELL_ROW_81_1221 VGND VPWR sky130_fd_sc_hd__tapvpwrvgnd_1
XFILLER_22_161 VGND VGND VPWR VPWR sky130_fd_sc_hd__fill_2
XFILLER_52_35 VGND VGND VPWR VPWR sky130_fd_sc_hd__decap_3
XFILLER_10_312 VGND VGND VPWR VPWR sky130_fd_sc_hd__decap_3
XFILLER_10_323 VGND VGND VPWR VPWR sky130_fd_sc_hd__decap_3
XFILLER_52_79 VGND VGND VPWR VPWR sky130_fd_sc_hd__decap_3
XFILLER_108_200 VGND VGND VPWR VPWR sky130_fd_sc_hd__decap_3
XFILLER_10_345 VGND VGND VPWR VPWR sky130_fd_sc_hd__decap_3
XFILLER_10_356 VGND VGND VPWR VPWR sky130_fd_sc_hd__decap_3
XFILLER_108_211 VGND VGND VPWR VPWR sky130_fd_sc_hd__decap_3
XTAP_TAPCELL_ROW_79_1194 VGND VPWR sky130_fd_sc_hd__tapvpwrvgnd_1
XFILLER_77_21 VGND VGND VPWR VPWR sky130_fd_sc_hd__decap_3
XTAP_TAPCELL_ROW_92_1361 VGND VPWR sky130_fd_sc_hd__tapvpwrvgnd_1
XTAP_TAPCELL_ROW_92_1350 VGND VPWR sky130_fd_sc_hd__tapvpwrvgnd_1
XFILLER_77_54 VGND VGND VPWR VPWR sky130_fd_sc_hd__fill_2
XFILLER_89_183 VGND VGND VPWR VPWR sky130_fd_sc_hd__decap_3
XFILLER_104_494 VGND VGND VPWR VPWR sky130_fd_sc_hd__decap_3
XFILLER_89_194 VGND VGND VPWR VPWR sky130_fd_sc_hd__decap_3
XFILLER_77_367 VGND VGND VPWR VPWR sky130_fd_sc_hd__decap_3
XFILLER_77_98 VGND VGND VPWR VPWR sky130_fd_sc_hd__decap_3
XFILLER_92_315 VGND VGND VPWR VPWR sky130_fd_sc_hd__decap_3
XFILLER_93_42 VGND VGND VPWR VPWR sky130_fd_sc_hd__decap_3
XFILLER_45_231 VGND VGND VPWR VPWR sky130_fd_sc_hd__decap_3
XFILLER_73_551 VGND VGND VPWR VPWR sky130_fd_sc_hd__decap_3
Xhold1090 _7262_/Q VGND VGND VPWR VPWR _4998_/A0 sky130_fd_sc_hd__dlygate4sd3_1
XFILLER_18_489 VGND VGND VPWR VPWR sky130_fd_sc_hd__fill_2
XFILLER_33_426 VGND VGND VPWR VPWR sky130_fd_sc_hd__decap_3
XFILLER_45_264 VGND VGND VPWR VPWR sky130_fd_sc_hd__decap_3
XFILLER_93_97 VGND VGND VPWR VPWR sky130_fd_sc_hd__decap_3
XFILLER_26_91 VGND VGND VPWR VPWR sky130_fd_sc_hd__decap_3
XFILLER_33_459 VGND VGND VPWR VPWR sky130_fd_sc_hd__fill_2
XFILLER_14_662 VGND VGND VPWR VPWR sky130_fd_sc_hd__decap_3
XFILLER_13_172 VGND VGND VPWR VPWR sky130_fd_sc_hd__decap_3
XTAP_TAPCELL_ROW_31_627 VGND VPWR sky130_fd_sc_hd__tapvpwrvgnd_1
XFILLER_9_110 VGND VGND VPWR VPWR sky130_fd_sc_hd__fill_2
XFILLER_42_90 VGND VGND VPWR VPWR sky130_fd_sc_hd__decap_3
X_3580_ _7033_/Q _4534_/S _4332_/B1 _7380_/Q VGND VGND VPWR VPWR _3580_/X sky130_fd_sc_hd__a22o_2
XFILLER_9_187 VGND VGND VPWR VPWR sky130_fd_sc_hd__fill_1
XTAP_TAPCELL_ROW_11_384 VGND VPWR sky130_fd_sc_hd__tapvpwrvgnd_1
XFILLER_114_203 VGND VGND VPWR VPWR sky130_fd_sc_hd__decap_3
XFILLER_114_236 VGND VGND VPWR VPWR sky130_fd_sc_hd__decap_3
XFILLER_102_409 VGND VGND VPWR VPWR sky130_fd_sc_hd__decap_3
XFILLER_47_3 VGND VGND VPWR VPWR sky130_fd_sc_hd__decap_3
XFILLER_5_393 VGND VGND VPWR VPWR sky130_fd_sc_hd__decap_3
X_4201_ _4186_/A _4636_/B _4200_/X VGND VGND VPWR VPWR _4201_/X sky130_fd_sc_hd__o21a_2
XFILLER_68_301 VGND VGND VPWR VPWR sky130_fd_sc_hd__decap_3
XFILLER_3_51 VGND VGND VPWR VPWR sky130_fd_sc_hd__decap_3
XFILLER_68_334 VGND VGND VPWR VPWR sky130_fd_sc_hd__decap_3
XFILLER_96_665 VGND VGND VPWR VPWR sky130_fd_sc_hd__decap_3
X_4132_ _7075_/Q _4432_/A2 _4142_/A _4131_/X VGND VGND VPWR VPWR _4207_/A sky130_fd_sc_hd__o211ai_2
XFILLER_28_209 VGND VGND VPWR VPWR sky130_fd_sc_hd__fill_1
XFILLER_3_84 VGND VGND VPWR VPWR sky130_fd_sc_hd__decap_3
XFILLER_68_389 VGND VGND VPWR VPWR sky130_fd_sc_hd__decap_3
XFILLER_95_153 VGND VGND VPWR VPWR sky130_fd_sc_hd__decap_3
X_4063_ _7116_/Q _4434_/A2 _4434_/B1 _7148_/Q VGND VGND VPWR VPWR _4063_/X sky130_fd_sc_hd__a22o_2
XTAP_TAPCELL_ROW_39_716 VGND VPWR sky130_fd_sc_hd__tapvpwrvgnd_1
XFILLER_36_231 VGND VGND VPWR VPWR sky130_fd_sc_hd__decap_3
XFILLER_36_253 VGND VGND VPWR VPWR sky130_fd_sc_hd__decap_3
XFILLER_64_584 VGND VGND VPWR VPWR sky130_fd_sc_hd__decap_3
XFILLER_24_459 VGND VGND VPWR VPWR sky130_fd_sc_hd__fill_2
X_4965_ _4965_/A0 _4964_/X _5028_/S VGND VGND VPWR VPWR _7264_/D sky130_fd_sc_hd__mux2_2
XTAP_TAPCELL_ROW_19_484 VGND VPWR sky130_fd_sc_hd__tapvpwrvgnd_1
X_6704_ _7384_/CLK _6704_/D VGND VGND VPWR VPWR _6704_/Q sky130_fd_sc_hd__dfxtp_2
XFILLER_20_643 VGND VGND VPWR VPWR sky130_fd_sc_hd__fill_1
X_4896_ _4896_/A _4896_/B VGND VGND VPWR VPWR _4896_/Y sky130_fd_sc_hd__nand2_2
XFILLER_22_27 VGND VGND VPWR VPWR sky130_fd_sc_hd__fill_1
X_6635_ _6635_/A VGND VGND VPWR VPWR _6635_/Y sky130_fd_sc_hd__inv_2
X_3847_ _6946_/Q _3878_/A2 _3892_/B1 _6958_/Q _3846_/X VGND VGND VPWR VPWR _3847_/X
+ sky130_fd_sc_hd__a221o_2
X_6566_ _6567_/A VGND VGND VPWR VPWR _6566_/Y sky130_fd_sc_hd__inv_2
X_3778_ _6930_/Q _3886_/A2 _3917_/B1 _6882_/Q VGND VGND VPWR VPWR _3778_/X sky130_fd_sc_hd__a22o_2
XTAP_TAPCELL_ROW_115_1626 VGND VPWR sky130_fd_sc_hd__tapvpwrvgnd_1
XFILLER_105_225 VGND VGND VPWR VPWR sky130_fd_sc_hd__decap_3
X_6497_ _6562_/A VGND VGND VPWR VPWR _6497_/Y sky130_fd_sc_hd__inv_2
XTAP_TAPCELL_ROW_115_1637 VGND VPWR sky130_fd_sc_hd__tapvpwrvgnd_1
Xoutput462 _5658_/A VGND VGND VPWR VPWR alu_result_out[10] sky130_fd_sc_hd__clkdlybuf4s25_1
XFILLER_87_610 VGND VGND VPWR VPWR sky130_fd_sc_hd__decap_3
Xoutput495 _5645_/X VGND VGND VPWR VPWR instruction_out[12] sky130_fd_sc_hd__clkdlybuf4s25_1
Xoutput484 _5655_/A VGND VGND VPWR VPWR alu_result_out[30] sky130_fd_sc_hd__clkdlybuf4s25_1
Xoutput473 place75/X VGND VGND VPWR VPWR alu_result_out[20] sky130_fd_sc_hd__clkdlybuf4s25_1
X_5379_ _5379_/A0 _4836_/X _5383_/S VGND VGND VPWR VPWR _7143_/D sky130_fd_sc_hd__mux2_2
XFILLER_101_420 VGND VGND VPWR VPWR sky130_fd_sc_hd__decap_3
XFILLER_59_334 VGND VGND VPWR VPWR sky130_fd_sc_hd__fill_2
X_7118_ _7374_/CLK _7118_/D _6398_/Y VGND VGND VPWR VPWR _7118_/Q sky130_fd_sc_hd__dfrtp_2
XFILLER_99_492 VGND VGND VPWR VPWR sky130_fd_sc_hd__fill_2
XFILLER_47_24 VGND VGND VPWR VPWR sky130_fd_sc_hd__decap_3
XFILLER_59_378 VGND VGND VPWR VPWR sky130_fd_sc_hd__decap_3
XFILLER_86_153 VGND VGND VPWR VPWR sky130_fd_sc_hd__decap_3
XFILLER_87_676 VGND VGND VPWR VPWR sky130_fd_sc_hd__decap_3
X_7049_ _7397_/CLK _7049_/D _6329_/Y VGND VGND VPWR VPWR _7049_/Q sky130_fd_sc_hd__dfrtp_2
XFILLER_101_486 VGND VGND VPWR VPWR sky130_fd_sc_hd__decap_3
XFILLER_47_57 VGND VGND VPWR VPWR sky130_fd_sc_hd__decap_3
XFILLER_86_197 VGND VGND VPWR VPWR sky130_fd_sc_hd__fill_1
XPHY_EDGE_ROW_29_Right_29 VGND VGND VPWR VPWR sky130_fd_sc_hd__decap_3
XFILLER_103_30 VGND VGND VPWR VPWR sky130_fd_sc_hd__decap_3
XFILLER_27_231 VGND VGND VPWR VPWR sky130_fd_sc_hd__decap_3
XFILLER_103_63 VGND VGND VPWR VPWR sky130_fd_sc_hd__decap_3
XFILLER_27_275 VGND VGND VPWR VPWR sky130_fd_sc_hd__decap_3
XFILLER_70_510 VGND VGND VPWR VPWR sky130_fd_sc_hd__decap_3
XFILLER_15_459 VGND VGND VPWR VPWR sky130_fd_sc_hd__decap_3
XFILLER_42_245 VGND VGND VPWR VPWR sky130_fd_sc_hd__decap_3
XFILLER_70_543 VGND VGND VPWR VPWR sky130_fd_sc_hd__fill_2
XFILLER_82_392 VGND VGND VPWR VPWR sky130_fd_sc_hd__decap_3
XFILLER_30_418 VGND VGND VPWR VPWR sky130_fd_sc_hd__fill_2
XFILLER_42_256 VGND VGND VPWR VPWR sky130_fd_sc_hd__decap_3
XFILLER_70_587 VGND VGND VPWR VPWR sky130_fd_sc_hd__fill_1
XFILLER_8_29 VGND VGND VPWR VPWR sky130_fd_sc_hd__decap_3
XFILLER_10_120 VGND VGND VPWR VPWR sky130_fd_sc_hd__decap_3
XFILLER_11_654 VGND VGND VPWR VPWR sky130_fd_sc_hd__fill_2
XFILLER_11_665 VGND VGND VPWR VPWR sky130_fd_sc_hd__decap_3
XFILLER_7_625 VGND VGND VPWR VPWR sky130_fd_sc_hd__fill_2
XPHY_EDGE_ROW_38_Right_38 VGND VGND VPWR VPWR sky130_fd_sc_hd__decap_3
XFILLER_109_520 VGND VGND VPWR VPWR sky130_fd_sc_hd__fill_1
XFILLER_109_542 VGND VGND VPWR VPWR sky130_fd_sc_hd__decap_3
XFILLER_6_124 VGND VGND VPWR VPWR sky130_fd_sc_hd__decap_3
XFILLER_7_647 VGND VGND VPWR VPWR sky130_fd_sc_hd__fill_1
Xwire567 _6982_/D VGND VGND VPWR VPWR wire567/X sky130_fd_sc_hd__clkbuf_2
XFILLER_109_564 VGND VGND VPWR VPWR sky130_fd_sc_hd__decap_3
XFILLER_88_64 VGND VGND VPWR VPWR sky130_fd_sc_hd__decap_3
XFILLER_2_352 VGND VGND VPWR VPWR sky130_fd_sc_hd__fill_1
XFILLER_2_374 VGND VGND VPWR VPWR sky130_fd_sc_hd__decap_3
XFILLER_33_9 VGND VGND VPWR VPWR sky130_fd_sc_hd__decap_3
XFILLER_88_97 VGND VGND VPWR VPWR sky130_fd_sc_hd__fill_2
XFILLER_78_654 VGND VGND VPWR VPWR sky130_fd_sc_hd__fill_1
XFILLER_38_529 VGND VGND VPWR VPWR sky130_fd_sc_hd__decap_3
XFILLER_78_676 VGND VGND VPWR VPWR sky130_fd_sc_hd__decap_3
XPHY_EDGE_ROW_47_Right_47 VGND VGND VPWR VPWR sky130_fd_sc_hd__decap_3
XFILLER_65_326 VGND VGND VPWR VPWR sky130_fd_sc_hd__decap_3
XFILLER_65_337 VGND VGND VPWR VPWR sky130_fd_sc_hd__decap_3
XFILLER_92_123 VGND VGND VPWR VPWR sky130_fd_sc_hd__decap_3
XFILLER_18_242 VGND VGND VPWR VPWR sky130_fd_sc_hd__decap_3
XFILLER_93_668 VGND VGND VPWR VPWR sky130_fd_sc_hd__decap_3
XFILLER_93_679 VGND VGND VPWR VPWR sky130_fd_sc_hd__decap_3
XFILLER_18_253 VGND VGND VPWR VPWR sky130_fd_sc_hd__decap_3
XFILLER_37_90 VGND VGND VPWR VPWR sky130_fd_sc_hd__decap_3
XFILLER_46_584 VGND VGND VPWR VPWR sky130_fd_sc_hd__decap_3
XFILLER_80_329 VGND VGND VPWR VPWR sky130_fd_sc_hd__decap_3
XFILLER_92_189 VGND VGND VPWR VPWR sky130_fd_sc_hd__decap_3
XFILLER_33_278 VGND VGND VPWR VPWR sky130_fd_sc_hd__fill_2
XTAP_TAPCELL_ROW_44_774 VGND VPWR sky130_fd_sc_hd__tapvpwrvgnd_1
XTAP_TAPCELL_ROW_16_443 VGND VPWR sky130_fd_sc_hd__tapvpwrvgnd_1
XFILLER_14_470 VGND VGND VPWR VPWR sky130_fd_sc_hd__decap_3
X_4750_ _4909_/A _4750_/B _4750_/C VGND VGND VPWR VPWR _4751_/B sky130_fd_sc_hd__or3_2
XTAP_TAPCELL_ROW_44_785 VGND VPWR sky130_fd_sc_hd__tapvpwrvgnd_1
XPHY_EDGE_ROW_56_Right_56 VGND VGND VPWR VPWR sky130_fd_sc_hd__decap_3
X_4681_ _4982_/B _5009_/A _6992_/Q _6993_/Q _6994_/Q VGND VGND VPWR VPWR _4960_/B
+ sky130_fd_sc_hd__o2111a_2
X_3701_ _3682_/A _3700_/X _3709_/B1 VGND VGND VPWR VPWR _3701_/X sky130_fd_sc_hd__a21o_2
X_6420_ _6548_/A VGND VGND VPWR VPWR _6420_/Y sky130_fd_sc_hd__inv_2
X_3632_ _3630_/A _3501_/X _3502_/X _3505_/B _5020_/A VGND VGND VPWR VPWR _3632_/X
+ sky130_fd_sc_hd__a311o_2
X_6351_ _6388_/A VGND VGND VPWR VPWR _6351_/Y sky130_fd_sc_hd__inv_2
X_5302_ _5302_/A0 _4771_/X _5323_/S VGND VGND VPWR VPWR _7179_/D sky130_fd_sc_hd__mux2_2
XFILLER_115_545 VGND VGND VPWR VPWR sky130_fd_sc_hd__decap_3
XFILLER_115_567 VGND VGND VPWR VPWR sky130_fd_sc_hd__decap_3
X_6282_ _6285_/A VGND VGND VPWR VPWR _6282_/Y sky130_fd_sc_hd__inv_2
X_3494_ _7183_/Q _4471_/S _4354_/B1 _7375_/Q VGND VGND VPWR VPWR _3494_/X sky130_fd_sc_hd__a22o_2
XFILLER_102_217 VGND VGND VPWR VPWR sky130_fd_sc_hd__decap_3
XPHY_EDGE_ROW_65_Right_65 VGND VGND VPWR VPWR sky130_fd_sc_hd__decap_3
XFILLER_56_304 VGND VGND VPWR VPWR sky130_fd_sc_hd__decap_3
XFILLER_68_153 VGND VGND VPWR VPWR sky130_fd_sc_hd__decap_3
XFILLER_69_676 VGND VGND VPWR VPWR sky130_fd_sc_hd__decap_3
XFILLER_84_613 VGND VGND VPWR VPWR sky130_fd_sc_hd__decap_3
X_4115_ _7268_/Q _4422_/A2 _4349_/B1 _7236_/Q _4114_/X VGND VGND VPWR VPWR _4117_/B
+ sky130_fd_sc_hd__a221o_2
XTAP_TAPCELL_ROW_110_1567 VGND VPWR sky130_fd_sc_hd__tapvpwrvgnd_1
XFILLER_110_283 VGND VGND VPWR VPWR sky130_fd_sc_hd__fill_2
XFILLER_56_315 VGND VGND VPWR VPWR sky130_fd_sc_hd__decap_3
XFILLER_56_337 VGND VGND VPWR VPWR sky130_fd_sc_hd__decap_3
XFILLER_68_186 VGND VGND VPWR VPWR sky130_fd_sc_hd__decap_3
XFILLER_68_197 VGND VGND VPWR VPWR sky130_fd_sc_hd__decap_3
XFILLER_83_101 VGND VGND VPWR VPWR sky130_fd_sc_hd__decap_3
XFILLER_96_495 VGND VGND VPWR VPWR sky130_fd_sc_hd__decap_3
X_5095_ _5095_/A0 _5094_/X _5126_/S VGND VGND VPWR VPWR _7256_/D sky130_fd_sc_hd__mux2_2
XFILLER_17_27 VGND VGND VPWR VPWR sky130_fd_sc_hd__decap_3
XFILLER_83_134 VGND VGND VPWR VPWR sky130_fd_sc_hd__decap_3
XFILLER_84_679 VGND VGND VPWR VPWR sky130_fd_sc_hd__decap_3
X_4046_ _7373_/Q _4435_/B1 _4436_/B1 _7181_/Q VGND VGND VPWR VPWR _4046_/X sky130_fd_sc_hd__a22o_2
XFILLER_52_510 VGND VGND VPWR VPWR sky130_fd_sc_hd__decap_3
XFILLER_24_234 VGND VGND VPWR VPWR sky130_fd_sc_hd__decap_3
XFILLER_92_690 VGND VGND VPWR VPWR sky130_fd_sc_hd__fill_2
XTAP_TAPCELL_ROW_65_1035 VGND VPWR sky130_fd_sc_hd__tapvpwrvgnd_1
XFILLER_24_256 VGND VGND VPWR VPWR sky130_fd_sc_hd__decap_3
XFILLER_52_587 VGND VGND VPWR VPWR sky130_fd_sc_hd__fill_1
XPHY_EDGE_ROW_74_Right_74 VGND VGND VPWR VPWR sky130_fd_sc_hd__decap_3
XFILLER_33_26 VGND VGND VPWR VPWR sky130_fd_sc_hd__decap_3
XFILLER_33_48 VGND VGND VPWR VPWR sky130_fd_sc_hd__decap_3
XFILLER_52_598 VGND VGND VPWR VPWR sky130_fd_sc_hd__decap_3
X_4948_ _4948_/A _4948_/B VGND VGND VPWR VPWR _4948_/Y sky130_fd_sc_hd__nor2_2
X_4879_ _4879_/A0 _4878_/X _4879_/S VGND VGND VPWR VPWR _7269_/D sky130_fd_sc_hd__mux2_2
X_6618_ _6682_/A VGND VGND VPWR VPWR _6618_/Y sky130_fd_sc_hd__inv_2
XFILLER_3_105 VGND VGND VPWR VPWR sky130_fd_sc_hd__decap_3
XFILLER_3_116 VGND VGND VPWR VPWR sky130_fd_sc_hd__decap_3
X_6549_ _6584_/A VGND VGND VPWR VPWR _6549_/Y sky130_fd_sc_hd__inv_2
XFILLER_106_545 VGND VGND VPWR VPWR sky130_fd_sc_hd__decap_3
XFILLER_106_567 VGND VGND VPWR VPWR sky130_fd_sc_hd__decap_3
XFILLER_3_149 VGND VGND VPWR VPWR sky130_fd_sc_hd__decap_3
XTAP_TAPCELL_ROW_76_1164 VGND VPWR sky130_fd_sc_hd__tapvpwrvgnd_1
XPHY_EDGE_ROW_83_Right_83 VGND VGND VPWR VPWR sky130_fd_sc_hd__decap_3
XPHY_EDGE_ROW_18_Left_135 VGND VGND VPWR VPWR sky130_fd_sc_hd__decap_3
XFILLER_106_589 VGND VGND VPWR VPWR sky130_fd_sc_hd__decap_3
XFILLER_79_429 VGND VGND VPWR VPWR sky130_fd_sc_hd__fill_1
XFILLER_58_56 VGND VGND VPWR VPWR sky130_fd_sc_hd__fill_2
XFILLER_59_120 VGND VGND VPWR VPWR sky130_fd_sc_hd__decap_3
XFILLER_47_304 VGND VGND VPWR VPWR sky130_fd_sc_hd__fill_1
XFILLER_58_78 VGND VGND VPWR VPWR sky130_fd_sc_hd__decap_3
XFILLER_59_164 VGND VGND VPWR VPWR sky130_fd_sc_hd__decap_3
XFILLER_47_337 VGND VGND VPWR VPWR sky130_fd_sc_hd__fill_2
XFILLER_59_175 VGND VGND VPWR VPWR sky130_fd_sc_hd__decap_3
XFILLER_114_62 VGND VGND VPWR VPWR sky130_fd_sc_hd__decap_3
XFILLER_74_11 VGND VGND VPWR VPWR sky130_fd_sc_hd__decap_3
XFILLER_75_668 VGND VGND VPWR VPWR sky130_fd_sc_hd__decap_3
XFILLER_75_679 VGND VGND VPWR VPWR sky130_fd_sc_hd__decap_3
XFILLER_90_605 VGND VGND VPWR VPWR sky130_fd_sc_hd__decap_3
XFILLER_74_167 VGND VGND VPWR VPWR sky130_fd_sc_hd__decap_3
XFILLER_74_44 VGND VGND VPWR VPWR sky130_fd_sc_hd__decap_3
XPHY_EDGE_ROW_27_Left_144 VGND VGND VPWR VPWR sky130_fd_sc_hd__decap_3
XFILLER_15_223 VGND VGND VPWR VPWR sky130_fd_sc_hd__fill_1
XFILLER_74_88 VGND VGND VPWR VPWR sky130_fd_sc_hd__fill_1
XTAP_TAPCELL_ROW_87_1293 VGND VPWR sky130_fd_sc_hd__tapvpwrvgnd_1
XPHY_EDGE_ROW_92_Right_92 VGND VGND VPWR VPWR sky130_fd_sc_hd__decap_3
XFILLER_15_267 VGND VGND VPWR VPWR sky130_fd_sc_hd__decap_3
XFILLER_70_340 VGND VGND VPWR VPWR sky130_fd_sc_hd__decap_3
XFILLER_30_215 VGND VGND VPWR VPWR sky130_fd_sc_hd__decap_3
XFILLER_70_384 VGND VGND VPWR VPWR sky130_fd_sc_hd__fill_2
XFILLER_90_32 VGND VGND VPWR VPWR sky130_fd_sc_hd__decap_3
XTAP_TAPCELL_ROW_13_413 VGND VPWR sky130_fd_sc_hd__tapvpwrvgnd_1
XTAP_TAPCELL_ROW_13_402 VGND VPWR sky130_fd_sc_hd__tapvpwrvgnd_1
XFILLER_90_76 VGND VGND VPWR VPWR sky130_fd_sc_hd__decap_3
XTAP_TAPCELL_ROW_41_744 VGND VPWR sky130_fd_sc_hd__tapvpwrvgnd_1
XFILLER_23_81 VGND VGND VPWR VPWR sky130_fd_sc_hd__decap_3
XFILLER_116_309 VGND VGND VPWR VPWR sky130_fd_sc_hd__fill_1
XPHY_EDGE_ROW_36_Left_153 VGND VGND VPWR VPWR sky130_fd_sc_hd__decap_3
XFILLER_99_30 VGND VGND VPWR VPWR sky130_fd_sc_hd__decap_3
XFILLER_99_63 VGND VGND VPWR VPWR sky130_fd_sc_hd__decap_3
XFILLER_99_96 VGND VGND VPWR VPWR sky130_fd_sc_hd__decap_3
XFILLER_3_650 VGND VGND VPWR VPWR sky130_fd_sc_hd__decap_3
XFILLER_112_548 VGND VGND VPWR VPWR sky130_fd_sc_hd__decap_3
XFILLER_38_304 VGND VGND VPWR VPWR sky130_fd_sc_hd__decap_3
XFILLER_66_613 VGND VGND VPWR VPWR sky130_fd_sc_hd__decap_3
XFILLER_78_451 VGND VGND VPWR VPWR sky130_fd_sc_hd__decap_3
XFILLER_38_315 VGND VGND VPWR VPWR sky130_fd_sc_hd__decap_3
XFILLER_65_101 VGND VGND VPWR VPWR sky130_fd_sc_hd__decap_3
XFILLER_78_495 VGND VGND VPWR VPWR sky130_fd_sc_hd__decap_3
XFILLER_65_156 VGND VGND VPWR VPWR sky130_fd_sc_hd__decap_3
XFILLER_66_657 VGND VGND VPWR VPWR sky130_fd_sc_hd__decap_3
XFILLER_81_605 VGND VGND VPWR VPWR sky130_fd_sc_hd__decap_3
XTAP_TAPCELL_ROW_49_844 VGND VPWR sky130_fd_sc_hd__tapvpwrvgnd_1
XPHY_EDGE_ROW_45_Left_162 VGND VGND VPWR VPWR sky130_fd_sc_hd__decap_3
XFILLER_0_41 VGND VGND VPWR VPWR sky130_fd_sc_hd__decap_3
XFILLER_65_178 VGND VGND VPWR VPWR sky130_fd_sc_hd__decap_3
XFILLER_93_476 VGND VGND VPWR VPWR sky130_fd_sc_hd__decap_3
XFILLER_0_74 VGND VGND VPWR VPWR sky130_fd_sc_hd__decap_3
XFILLER_0_85 VGND VGND VPWR VPWR sky130_fd_sc_hd__fill_1
XFILLER_74_690 VGND VGND VPWR VPWR sky130_fd_sc_hd__fill_2
XFILLER_61_340 VGND VGND VPWR VPWR sky130_fd_sc_hd__decap_3
XFILLER_21_237 VGND VGND VPWR VPWR sky130_fd_sc_hd__decap_3
X_4802_ _7002_/Q _5605_/B _4834_/A VGND VGND VPWR VPWR _4802_/X sky130_fd_sc_hd__o21a_2
XPHY_EDGE_ROW_100_Right_100 VGND VGND VPWR VPWR sky130_fd_sc_hd__decap_3
XFILLER_9_72 VGND VGND VPWR VPWR sky130_fd_sc_hd__decap_3
XPHY_EDGE_ROW_54_Left_171 VGND VGND VPWR VPWR sky130_fd_sc_hd__decap_3
X_6403_ _6599_/A VGND VGND VPWR VPWR _6403_/Y sky130_fd_sc_hd__inv_2
X_4664_ _5015_/A _4664_/B _5665_/A VGND VGND VPWR VPWR _4664_/X sky130_fd_sc_hd__or3b_4
X_7383_ _7387_/CLK _7383_/D _6663_/Y VGND VGND VPWR VPWR _7383_/Q sky130_fd_sc_hd__dfrtp_2
Xhold901 _7090_/Q VGND VGND VPWR VPWR _7090_/D sky130_fd_sc_hd__dlygate4sd3_1
Xhold912 _6705_/Q VGND VGND VPWR VPWR hold912/X sky130_fd_sc_hd__dlygate4sd3_1
X_4595_ _4595_/A _4595_/B VGND VGND VPWR VPWR _7283_/D sky130_fd_sc_hd__and2_2
X_3615_ _3508_/A _3547_/Y _3427_/B VGND VGND VPWR VPWR _3616_/B sky130_fd_sc_hd__o21ai_2
Xhold923 _5686_/X VGND VGND VPWR VPWR _6693_/D sky130_fd_sc_hd__dlygate4sd3_1
Xhold934 _6700_/Q VGND VGND VPWR VPWR hold934/X sky130_fd_sc_hd__dlygate4sd3_1
Xhold945 _6690_/Q VGND VGND VPWR VPWR hold945/X sky130_fd_sc_hd__dlygate4sd3_1
X_6334_ _6684_/A VGND VGND VPWR VPWR _6334_/Y sky130_fd_sc_hd__inv_2
X_3546_ _3630_/A _3630_/B _3635_/A _3636_/A VGND VGND VPWR VPWR _3547_/B sky130_fd_sc_hd__a211o_2
XFILLER_1_609 VGND VGND VPWR VPWR sky130_fd_sc_hd__decap_3
XFILLER_88_215 VGND VGND VPWR VPWR sky130_fd_sc_hd__decap_3
Xhold989 _7032_/Q VGND VGND VPWR VPWR _5591_/A sky130_fd_sc_hd__dlygate4sd3_1
Xhold978 _7398_/Q VGND VGND VPWR VPWR hold978/X sky130_fd_sc_hd__dlygate4sd3_1
Xhold967 _7406_/Q VGND VGND VPWR VPWR hold967/X sky130_fd_sc_hd__dlygate4sd3_1
Xhold956 _6718_/Q VGND VGND VPWR VPWR hold956/X sky130_fd_sc_hd__dlygate4sd3_1
X_6265_ _6522_/A VGND VGND VPWR VPWR _6265_/Y sky130_fd_sc_hd__inv_2
X_3477_ _7184_/Q _3996_/S _4346_/B1 _7376_/Q VGND VGND VPWR VPWR _3477_/X sky130_fd_sc_hd__a22o_2
XFILLER_28_37 VGND VGND VPWR VPWR sky130_fd_sc_hd__decap_3
XFILLER_29_337 VGND VGND VPWR VPWR sky130_fd_sc_hd__decap_3
XFILLER_57_635 VGND VGND VPWR VPWR sky130_fd_sc_hd__decap_3
XFILLER_84_421 VGND VGND VPWR VPWR sky130_fd_sc_hd__decap_3
XFILLER_96_281 VGND VGND VPWR VPWR sky130_fd_sc_hd__decap_3
X_5147_ _5145_/A _3541_/X _5146_/Y VGND VGND VPWR VPWR _5147_/X sky130_fd_sc_hd__a21o_2
XPHY_EDGE_ROW_63_Left_180 VGND VGND VPWR VPWR sky130_fd_sc_hd__decap_3
XFILLER_57_668 VGND VGND VPWR VPWR sky130_fd_sc_hd__decap_3
XFILLER_57_679 VGND VGND VPWR VPWR sky130_fd_sc_hd__decap_3
XFILLER_84_454 VGND VGND VPWR VPWR sky130_fd_sc_hd__decap_3
X_5078_ _5581_/S _5069_/X _5077_/X _4467_/B _5666_/A VGND VGND VPWR VPWR _5078_/X
+ sky130_fd_sc_hd__a221o_2
XFILLER_44_318 VGND VGND VPWR VPWR sky130_fd_sc_hd__decap_3
XFILLER_56_178 VGND VGND VPWR VPWR sky130_fd_sc_hd__decap_3
XFILLER_56_189 VGND VGND VPWR VPWR sky130_fd_sc_hd__decap_3
XFILLER_71_104 VGND VGND VPWR VPWR sky130_fd_sc_hd__decap_3
XFILLER_72_616 VGND VGND VPWR VPWR sky130_fd_sc_hd__decap_3
XFILLER_25_521 VGND VGND VPWR VPWR sky130_fd_sc_hd__decap_3
XFILLER_71_126 VGND VGND VPWR VPWR sky130_fd_sc_hd__decap_3
XFILLER_25_554 VGND VGND VPWR VPWR sky130_fd_sc_hd__decap_3
XFILLER_44_58 VGND VGND VPWR VPWR sky130_fd_sc_hd__decap_3
XFILLER_52_351 VGND VGND VPWR VPWR sky130_fd_sc_hd__decap_3
XFILLER_12_215 VGND VGND VPWR VPWR sky130_fd_sc_hd__decap_3
XFILLER_100_53 VGND VGND VPWR VPWR sky130_fd_sc_hd__decap_3
XFILLER_8_208 VGND VGND VPWR VPWR sky130_fd_sc_hd__decap_3
XFILLER_100_97 VGND VGND VPWR VPWR sky130_fd_sc_hd__decap_3
XFILLER_60_35 VGND VGND VPWR VPWR sky130_fd_sc_hd__decap_3
XFILLER_60_57 VGND VGND VPWR VPWR sky130_fd_sc_hd__decap_3
XFILLER_114_3 VGND VGND VPWR VPWR sky130_fd_sc_hd__decap_3
XFILLER_4_414 VGND VGND VPWR VPWR sky130_fd_sc_hd__decap_3
XFILLER_109_51 VGND VGND VPWR VPWR sky130_fd_sc_hd__decap_3
XFILLER_4_458 VGND VGND VPWR VPWR sky130_fd_sc_hd__fill_1
XFILLER_106_353 VGND VGND VPWR VPWR sky130_fd_sc_hd__fill_2
XFILLER_109_84 VGND VGND VPWR VPWR sky130_fd_sc_hd__decap_3
XFILLER_69_33 VGND VGND VPWR VPWR sky130_fd_sc_hd__decap_3
XFILLER_69_66 VGND VGND VPWR VPWR sky130_fd_sc_hd__decap_3
XFILLER_0_620 VGND VGND VPWR VPWR sky130_fd_sc_hd__decap_3
XFILLER_79_259 VGND VGND VPWR VPWR sky130_fd_sc_hd__decap_3
XFILLER_48_624 VGND VGND VPWR VPWR sky130_fd_sc_hd__decap_3
XFILLER_87_270 VGND VGND VPWR VPWR sky130_fd_sc_hd__decap_3
XFILLER_87_281 VGND VGND VPWR VPWR sky130_fd_sc_hd__decap_3
XFILLER_94_218 VGND VGND VPWR VPWR sky130_fd_sc_hd__decap_3
XTAP_TAPCELL_ROW_89_1322 VGND VPWR sky130_fd_sc_hd__tapvpwrvgnd_1
XFILLER_48_657 VGND VGND VPWR VPWR sky130_fd_sc_hd__decap_3
XFILLER_75_432 VGND VGND VPWR VPWR sky130_fd_sc_hd__decap_3
XFILLER_35_307 VGND VGND VPWR VPWR sky130_fd_sc_hd__decap_3
XFILLER_47_178 VGND VGND VPWR VPWR sky130_fd_sc_hd__decap_3
XFILLER_63_638 VGND VGND VPWR VPWR sky130_fd_sc_hd__decap_3
XFILLER_75_476 VGND VGND VPWR VPWR sky130_fd_sc_hd__decap_3
XFILLER_85_87 VGND VGND VPWR VPWR sky130_fd_sc_hd__decap_3
XTAP_TAPCELL_ROW_46_803 VGND VPWR sky130_fd_sc_hd__tapvpwrvgnd_1
XFILLER_56_690 VGND VGND VPWR VPWR sky130_fd_sc_hd__fill_2
XFILLER_62_126 VGND VGND VPWR VPWR sky130_fd_sc_hd__decap_3
XFILLER_90_424 VGND VGND VPWR VPWR sky130_fd_sc_hd__decap_3
XFILLER_16_565 VGND VGND VPWR VPWR sky130_fd_sc_hd__fill_1
XFILLER_31_535 VGND VGND VPWR VPWR sky130_fd_sc_hd__decap_3
XFILLER_70_181 VGND VGND VPWR VPWR sky130_fd_sc_hd__decap_3
XFILLER_71_682 VGND VGND VPWR VPWR sky130_fd_sc_hd__decap_3
XTAP_TAPCELL_ROW_26_560 VGND VPWR sky130_fd_sc_hd__tapvpwrvgnd_1
XFILLER_11_281 VGND VGND VPWR VPWR sky130_fd_sc_hd__decap_3
XFILLER_79_6 VGND VGND VPWR VPWR sky130_fd_sc_hd__decap_3
XFILLER_116_106 VGND VGND VPWR VPWR sky130_fd_sc_hd__decap_3
X_4380_ _4380_/A _4380_/B VGND VGND VPWR VPWR _4381_/B sky130_fd_sc_hd__or2_2
X_3400_ _3449_/B VGND VGND VPWR VPWR _3421_/B sky130_fd_sc_hd__inv_2
X_3331_ _3365_/A _3362_/A _3369_/A VGND VGND VPWR VPWR _3528_/A sky130_fd_sc_hd__or3b_2
XFILLER_98_546 VGND VGND VPWR VPWR sky130_fd_sc_hd__decap_3
XFILLER_100_507 VGND VGND VPWR VPWR sky130_fd_sc_hd__decap_3
XFILLER_98_579 VGND VGND VPWR VPWR sky130_fd_sc_hd__fill_2
XFILLER_78_281 VGND VGND VPWR VPWR sky130_fd_sc_hd__fill_1
XFILLER_85_218 VGND VGND VPWR VPWR sky130_fd_sc_hd__decap_3
X_5001_ _5001_/A _5001_/B VGND VGND VPWR VPWR _6991_/D sky130_fd_sc_hd__nor2_2
XFILLER_39_668 VGND VGND VPWR VPWR sky130_fd_sc_hd__decap_3
XFILLER_66_443 VGND VGND VPWR VPWR sky130_fd_sc_hd__decap_3
XFILLER_93_240 VGND VGND VPWR VPWR sky130_fd_sc_hd__decap_3
XFILLER_26_307 VGND VGND VPWR VPWR sky130_fd_sc_hd__fill_1
XFILLER_38_156 VGND VGND VPWR VPWR sky130_fd_sc_hd__decap_3
XFILLER_39_679 VGND VGND VPWR VPWR sky130_fd_sc_hd__decap_3
XFILLER_54_616 VGND VGND VPWR VPWR sky130_fd_sc_hd__decap_3
XFILLER_81_402 VGND VGND VPWR VPWR sky130_fd_sc_hd__decap_3
XFILLER_38_189 VGND VGND VPWR VPWR sky130_fd_sc_hd__decap_3
XFILLER_53_137 VGND VGND VPWR VPWR sky130_fd_sc_hd__decap_3
X_6952_ _6964_/CLK _6952_/D VGND VGND VPWR VPWR _6952_/Q sky130_fd_sc_hd__dfxtp_2
XFILLER_62_660 VGND VGND VPWR VPWR sky130_fd_sc_hd__decap_3
X_6883_ _7230_/CLK _6883_/D VGND VGND VPWR VPWR _6883_/Q sky130_fd_sc_hd__dfxtp_2
XFILLER_34_373 VGND VGND VPWR VPWR sky130_fd_sc_hd__decap_3
XFILLER_34_395 VGND VGND VPWR VPWR sky130_fd_sc_hd__decap_3
XFILLER_61_181 VGND VGND VPWR VPWR sky130_fd_sc_hd__decap_3
X_4716_ _4606_/Y _4664_/X _4695_/X _7008_/D _4997_/A1 VGND VGND VPWR VPWR _4716_/X
+ sky130_fd_sc_hd__a32o_2
XFILLER_107_106 VGND VGND VPWR VPWR sky130_fd_sc_hd__decap_3
XFILLER_30_38 VGND VGND VPWR VPWR sky130_fd_sc_hd__decap_3
X_4647_ _4813_/A _4827_/A _4647_/C _4787_/A VGND VGND VPWR VPWR _4647_/X sky130_fd_sc_hd__and4_2
X_7366_ _7403_/CLK _7366_/D _6646_/Y VGND VGND VPWR VPWR _7366_/Q sky130_fd_sc_hd__dfrtp_2
Xhold720 _6822_/Q VGND VGND VPWR VPWR _6822_/D sky130_fd_sc_hd__dlygate4sd3_1
XFILLER_100_9 VGND VGND VPWR VPWR sky130_fd_sc_hd__decap_3
XFILLER_116_651 VGND VGND VPWR VPWR sky130_fd_sc_hd__decap_3
XFILLER_116_673 VGND VGND VPWR VPWR sky130_fd_sc_hd__decap_3
XFILLER_1_417 VGND VGND VPWR VPWR sky130_fd_sc_hd__decap_3
Xhold731 _6948_/Q VGND VGND VPWR VPWR _6948_/D sky130_fd_sc_hd__dlygate4sd3_1
Xhold742 _6972_/Q VGND VGND VPWR VPWR _6972_/D sky130_fd_sc_hd__dlygate4sd3_1
Xhold753 _6859_/Q VGND VGND VPWR VPWR _6859_/D sky130_fd_sc_hd__dlygate4sd3_1
Xhold764 _6820_/Q VGND VGND VPWR VPWR _6820_/D sky130_fd_sc_hd__dlygate4sd3_1
X_6317_ _6562_/A VGND VGND VPWR VPWR _6317_/Y sky130_fd_sc_hd__inv_2
XTAP_TAPCELL_ROW_73_1123 VGND VPWR sky130_fd_sc_hd__tapvpwrvgnd_1
XFILLER_103_301 VGND VGND VPWR VPWR sky130_fd_sc_hd__decap_3
XFILLER_115_161 VGND VGND VPWR VPWR sky130_fd_sc_hd__decap_3
XFILLER_115_172 VGND VGND VPWR VPWR sky130_fd_sc_hd__decap_3
X_7297_ _7363_/CLK _7297_/D _6577_/Y VGND VGND VPWR VPWR _7297_/Q sky130_fd_sc_hd__dfrtp_2
Xhold775 _6890_/Q VGND VGND VPWR VPWR _6890_/D sky130_fd_sc_hd__dlygate4sd3_1
Xhold786 _6913_/Q VGND VGND VPWR VPWR _6913_/D sky130_fd_sc_hd__dlygate4sd3_1
Xhold797 _6923_/Q VGND VGND VPWR VPWR _6923_/D sky130_fd_sc_hd__dlygate4sd3_1
XFILLER_103_389 VGND VGND VPWR VPWR sky130_fd_sc_hd__decap_3
XFILLER_57_421 VGND VGND VPWR VPWR sky130_fd_sc_hd__fill_1
XFILLER_76_218 VGND VGND VPWR VPWR sky130_fd_sc_hd__decap_3
XFILLER_29_134 VGND VGND VPWR VPWR sky130_fd_sc_hd__fill_2
XFILLER_29_145 VGND VGND VPWR VPWR sky130_fd_sc_hd__fill_1
XFILLER_29_167 VGND VGND VPWR VPWR sky130_fd_sc_hd__fill_1
XFILLER_29_178 VGND VGND VPWR VPWR sky130_fd_sc_hd__decap_3
XFILLER_55_24 VGND VGND VPWR VPWR sky130_fd_sc_hd__decap_3
XFILLER_72_413 VGND VGND VPWR VPWR sky130_fd_sc_hd__decap_3
XTAP_TAPCELL_ROW_4_299 VGND VPWR sky130_fd_sc_hd__tapvpwrvgnd_1
XFILLER_17_329 VGND VGND VPWR VPWR sky130_fd_sc_hd__decap_3
XFILLER_45_638 VGND VGND VPWR VPWR sky130_fd_sc_hd__decap_3
XFILLER_55_57 VGND VGND VPWR VPWR sky130_fd_sc_hd__decap_3
XFILLER_72_424 VGND VGND VPWR VPWR sky130_fd_sc_hd__decap_3
XFILLER_60_619 VGND VGND VPWR VPWR sky130_fd_sc_hd__decap_3
XFILLER_72_468 VGND VGND VPWR VPWR sky130_fd_sc_hd__decap_3
XFILLER_111_52 VGND VGND VPWR VPWR sky130_fd_sc_hd__decap_3
XFILLER_111_63 VGND VGND VPWR VPWR sky130_fd_sc_hd__decap_3
XFILLER_25_384 VGND VGND VPWR VPWR sky130_fd_sc_hd__decap_3
XFILLER_53_682 VGND VGND VPWR VPWR sky130_fd_sc_hd__fill_2
XTAP_TAPCELL_ROW_84_1263 VGND VPWR sky130_fd_sc_hd__tapvpwrvgnd_1
XFILLER_111_96 VGND VGND VPWR VPWR sky130_fd_sc_hd__decap_3
XFILLER_13_557 VGND VGND VPWR VPWR sky130_fd_sc_hd__decap_3
XFILLER_40_321 VGND VGND VPWR VPWR sky130_fd_sc_hd__decap_3
XFILLER_40_332 VGND VGND VPWR VPWR sky130_fd_sc_hd__decap_3
XFILLER_52_192 VGND VGND VPWR VPWR sky130_fd_sc_hd__decap_3
XTAP_TAPCELL_ROW_23_530 VGND VPWR sky130_fd_sc_hd__tapvpwrvgnd_1
XFILLER_40_365 VGND VGND VPWR VPWR sky130_fd_sc_hd__decap_3
XTAP_TAPCELL_ROW_51_861 VGND VPWR sky130_fd_sc_hd__tapvpwrvgnd_1
XFILLER_4_200 VGND VGND VPWR VPWR sky130_fd_sc_hd__decap_3
XFILLER_107_662 VGND VGND VPWR VPWR sky130_fd_sc_hd__decap_3
XFILLER_107_673 VGND VGND VPWR VPWR sky130_fd_sc_hd__decap_3
XFILLER_20_82 VGND VGND VPWR VPWR sky130_fd_sc_hd__fill_2
XFILLER_96_20 VGND VGND VPWR VPWR sky130_fd_sc_hd__decap_3
XTAP_TAPCELL_ROW_95_1392 VGND VPWR sky130_fd_sc_hd__tapvpwrvgnd_1
XFILLER_106_194 VGND VGND VPWR VPWR sky130_fd_sc_hd__fill_2
XFILLER_96_53 VGND VGND VPWR VPWR sky130_fd_sc_hd__decap_3
XFILLER_0_461 VGND VGND VPWR VPWR sky130_fd_sc_hd__decap_3
XFILLER_48_410 VGND VGND VPWR VPWR sky130_fd_sc_hd__decap_3
XFILLER_95_538 VGND VGND VPWR VPWR sky130_fd_sc_hd__decap_3
XFILLER_96_64 VGND VGND VPWR VPWR sky130_fd_sc_hd__decap_3
XFILLER_48_421 VGND VGND VPWR VPWR sky130_fd_sc_hd__fill_2
XFILLER_63_402 VGND VGND VPWR VPWR sky130_fd_sc_hd__decap_3
XTAP_TAPCELL_ROW_59_961 VGND VPWR sky130_fd_sc_hd__tapvpwrvgnd_1
XFILLER_29_690 VGND VGND VPWR VPWR sky130_fd_sc_hd__fill_2
XFILLER_35_137 VGND VGND VPWR VPWR sky130_fd_sc_hd__decap_3
XFILLER_75_284 VGND VGND VPWR VPWR sky130_fd_sc_hd__decap_3
Xplace402 _4503_/S VGND VGND VPWR VPWR _4517_/S sky130_fd_sc_hd__buf_2
Xplace413 _4346_/B1 VGND VGND VPWR VPWR _4332_/B1 sky130_fd_sc_hd__buf_2
XFILLER_16_351 VGND VGND VPWR VPWR sky130_fd_sc_hd__decap_3
XFILLER_44_660 VGND VGND VPWR VPWR sky130_fd_sc_hd__decap_3
Xplace424 _3973_/S VGND VGND VPWR VPWR _3979_/S sky130_fd_sc_hd__buf_2
Xplace435 _3344_/Y VGND VGND VPWR VPWR _4677_/B sky130_fd_sc_hd__buf_2
Xplace446 _3318_/B VGND VGND VPWR VPWR _4230_/A2 sky130_fd_sc_hd__buf_2
XFILLER_45_90 VGND VGND VPWR VPWR sky130_fd_sc_hd__decap_3
XFILLER_50_118 VGND VGND VPWR VPWR sky130_fd_sc_hd__fill_1
XFILLER_50_129 VGND VGND VPWR VPWR sky130_fd_sc_hd__decap_3
XFILLER_90_298 VGND VGND VPWR VPWR sky130_fd_sc_hd__decap_3
Xplace457 _3353_/A VGND VGND VPWR VPWR _3365_/A sky130_fd_sc_hd__buf_2
XFILLER_31_332 VGND VGND VPWR VPWR sky130_fd_sc_hd__decap_3
XFILLER_43_181 VGND VGND VPWR VPWR sky130_fd_sc_hd__fill_2
XFILLER_43_192 VGND VGND VPWR VPWR sky130_fd_sc_hd__decap_3
X_3880_ _3714_/X _3877_/X _3879_/X _3735_/X VGND VGND VPWR VPWR _3880_/X sky130_fd_sc_hd__a22o_2
XFILLER_77_3 VGND VGND VPWR VPWR sky130_fd_sc_hd__decap_3
X_4501_ _4501_/A0 _4567_/A _4501_/S VGND VGND VPWR VPWR _7329_/D sky130_fd_sc_hd__mux2_2
X_7220_ clkload8/A _7220_/D _6500_/Y VGND VGND VPWR VPWR _7220_/Q sky130_fd_sc_hd__dfrtp_2
X_4432_ _7079_/Q _4432_/A2 _4205_/A _4431_/X VGND VGND VPWR VPWR _4440_/A sky130_fd_sc_hd__o211ai_2
XFILLER_6_62 VGND VGND VPWR VPWR sky130_fd_sc_hd__decap_3
XFILLER_113_632 VGND VGND VPWR VPWR sky130_fd_sc_hd__decap_3
XFILLER_116_19 VGND VGND VPWR VPWR sky130_fd_sc_hd__fill_1
X_7151_ _7356_/CLK _7151_/D _6431_/Y VGND VGND VPWR VPWR _7151_/Q sky130_fd_sc_hd__dfrtp_2
X_4363_ _4619_/B VGND VGND VPWR VPWR _4369_/A sky130_fd_sc_hd__inv_2
XFILLER_113_665 VGND VGND VPWR VPWR sky130_fd_sc_hd__decap_3
XFILLER_113_676 VGND VGND VPWR VPWR sky130_fd_sc_hd__decap_3
X_7082_ _7266_/CLK _7082_/D _6362_/Y VGND VGND VPWR VPWR _7082_/Q sky130_fd_sc_hd__dfrtp_2
X_4294_ _4294_/A _4612_/B VGND VGND VPWR VPWR _5113_/A sky130_fd_sc_hd__xor2_2
X_3314_ _4467_/A _4467_/B VGND VGND VPWR VPWR _5647_/A sky130_fd_sc_hd__or2_2
XFILLER_98_365 VGND VGND VPWR VPWR sky130_fd_sc_hd__decap_3
XFILLER_98_354 VGND VGND VPWR VPWR sky130_fd_sc_hd__decap_3
XFILLER_100_304 VGND VGND VPWR VPWR sky130_fd_sc_hd__decap_3
XFILLER_100_315 VGND VGND VPWR VPWR sky130_fd_sc_hd__decap_3
XFILLER_112_153 VGND VGND VPWR VPWR sky130_fd_sc_hd__decap_3
XFILLER_112_186 VGND VGND VPWR VPWR sky130_fd_sc_hd__decap_3
XFILLER_58_218 VGND VGND VPWR VPWR sky130_fd_sc_hd__decap_3
XFILLER_98_398 VGND VGND VPWR VPWR sky130_fd_sc_hd__decap_3
XFILLER_100_359 VGND VGND VPWR VPWR sky130_fd_sc_hd__decap_3
XFILLER_112_197 VGND VGND VPWR VPWR sky130_fd_sc_hd__decap_3
XFILLER_39_476 VGND VGND VPWR VPWR sky130_fd_sc_hd__fill_1
XFILLER_94_560 VGND VGND VPWR VPWR sky130_fd_sc_hd__decap_3
XFILLER_26_115 VGND VGND VPWR VPWR sky130_fd_sc_hd__decap_3
XFILLER_54_435 VGND VGND VPWR VPWR sky130_fd_sc_hd__fill_2
XFILLER_81_210 VGND VGND VPWR VPWR sky130_fd_sc_hd__decap_3
XTAP_TAPCELL_ROW_1_258 VGND VPWR sky130_fd_sc_hd__tapvpwrvgnd_1
XTAP_TAPCELL_ROW_107_1539 VGND VPWR sky130_fd_sc_hd__tapvpwrvgnd_1
XFILLER_26_159 VGND VGND VPWR VPWR sky130_fd_sc_hd__decap_3
XFILLER_42_619 VGND VGND VPWR VPWR sky130_fd_sc_hd__decap_3
XFILLER_81_243 VGND VGND VPWR VPWR sky130_fd_sc_hd__fill_1
XFILLER_81_265 VGND VGND VPWR VPWR sky130_fd_sc_hd__decap_3
X_6935_ _6959_/CLK _6935_/D VGND VGND VPWR VPWR _6935_/Q sky130_fd_sc_hd__dfxtp_2
XTAP_TAPCELL_ROW_1_269 VGND VPWR sky130_fd_sc_hd__tapvpwrvgnd_1
XFILLER_25_38 VGND VGND VPWR VPWR sky130_fd_sc_hd__decap_3
XFILLER_81_298 VGND VGND VPWR VPWR sky130_fd_sc_hd__decap_3
XTAP_TAPCELL_ROW_37_699 VGND VPWR sky130_fd_sc_hd__tapvpwrvgnd_1
XFILLER_22_343 VGND VGND VPWR VPWR sky130_fd_sc_hd__fill_2
XFILLER_34_192 VGND VGND VPWR VPWR sky130_fd_sc_hd__decap_3
XFILLER_50_630 VGND VGND VPWR VPWR sky130_fd_sc_hd__decap_3
X_6866_ _7387_/CLK _6866_/D VGND VGND VPWR VPWR _6866_/Q sky130_fd_sc_hd__dfxtp_2
XFILLER_22_365 VGND VGND VPWR VPWR sky130_fd_sc_hd__decap_3
XFILLER_50_663 VGND VGND VPWR VPWR sky130_fd_sc_hd__decap_3
X_6797_ _7005_/CLK _6797_/D VGND VGND VPWR VPWR _6797_/Q sky130_fd_sc_hd__dfxtp_2
XFILLER_10_527 VGND VGND VPWR VPWR sky130_fd_sc_hd__decap_3
XFILLER_22_398 VGND VGND VPWR VPWR sky130_fd_sc_hd__decap_3
XFILLER_41_26 VGND VGND VPWR VPWR sky130_fd_sc_hd__decap_3
XFILLER_108_415 VGND VGND VPWR VPWR sky130_fd_sc_hd__decap_3
XFILLER_116_492 VGND VGND VPWR VPWR sky130_fd_sc_hd__decap_3
XFILLER_89_321 VGND VGND VPWR VPWR sky130_fd_sc_hd__decap_3
X_7349_ clkload4/A _7349_/D _6629_/Y VGND VGND VPWR VPWR _7349_/Q sky130_fd_sc_hd__dfrtp_2
XTAP_TAPCELL_ROW_9_358 VGND VPWR sky130_fd_sc_hd__tapvpwrvgnd_1
XFILLER_9_6 VGND VGND VPWR VPWR sky130_fd_sc_hd__decap_3
XFILLER_103_120 VGND VGND VPWR VPWR sky130_fd_sc_hd__decap_3
XFILLER_104_654 VGND VGND VPWR VPWR sky130_fd_sc_hd__decap_3
XFILLER_1_258 VGND VGND VPWR VPWR sky130_fd_sc_hd__fill_1
XFILLER_77_505 VGND VGND VPWR VPWR sky130_fd_sc_hd__fill_1
Xhold583 _6796_/Q VGND VGND VPWR VPWR _6796_/D sky130_fd_sc_hd__dlygate4sd3_1
Xhold594 _6911_/Q VGND VGND VPWR VPWR _6911_/D sky130_fd_sc_hd__dlygate4sd3_1
XFILLER_104_687 VGND VGND VPWR VPWR sky130_fd_sc_hd__decap_3
XFILLER_106_41 VGND VGND VPWR VPWR sky130_fd_sc_hd__decap_3
XFILLER_77_538 VGND VGND VPWR VPWR sky130_fd_sc_hd__decap_3
XFILLER_106_74 VGND VGND VPWR VPWR sky130_fd_sc_hd__fill_1
XFILLER_106_85 VGND VGND VPWR VPWR sky130_fd_sc_hd__decap_3
XFILLER_66_45 VGND VGND VPWR VPWR sky130_fd_sc_hd__decap_3
XFILLER_57_251 VGND VGND VPWR VPWR sky130_fd_sc_hd__fill_1
XFILLER_17_126 VGND VGND VPWR VPWR sky130_fd_sc_hd__decap_3
XFILLER_18_638 VGND VGND VPWR VPWR sky130_fd_sc_hd__decap_3
XFILLER_45_435 VGND VGND VPWR VPWR sky130_fd_sc_hd__decap_3
XFILLER_57_284 VGND VGND VPWR VPWR sky130_fd_sc_hd__decap_3
XFILLER_66_89 VGND VGND VPWR VPWR sky130_fd_sc_hd__decap_3
XFILLER_85_582 VGND VGND VPWR VPWR sky130_fd_sc_hd__decap_3
XTAP_TAPCELL_ROW_56_920 VGND VPWR sky130_fd_sc_hd__tapvpwrvgnd_1
XFILLER_17_159 VGND VGND VPWR VPWR sky130_fd_sc_hd__decap_3
XFILLER_72_232 VGND VGND VPWR VPWR sky130_fd_sc_hd__decap_3
XFILLER_82_22 VGND VGND VPWR VPWR sky130_fd_sc_hd__decap_3
XFILLER_60_449 VGND VGND VPWR VPWR sky130_fd_sc_hd__fill_2
XFILLER_82_77 VGND VGND VPWR VPWR sky130_fd_sc_hd__decap_3
XFILLER_82_88 VGND VGND VPWR VPWR sky130_fd_sc_hd__decap_3
XFILLER_13_365 VGND VGND VPWR VPWR sky130_fd_sc_hd__decap_3
XFILLER_15_60 VGND VGND VPWR VPWR sky130_fd_sc_hd__decap_3
XFILLER_41_685 VGND VGND VPWR VPWR sky130_fd_sc_hd__decap_3
XFILLER_9_314 VGND VGND VPWR VPWR sky130_fd_sc_hd__fill_1
XFILLER_40_195 VGND VGND VPWR VPWR sky130_fd_sc_hd__fill_1
XTAP_TAPCELL_ROW_97_1421 VGND VPWR sky130_fd_sc_hd__tapvpwrvgnd_1
XTAP_TAPCELL_ROW_97_1410 VGND VPWR sky130_fd_sc_hd__tapvpwrvgnd_1
XFILLER_31_92 VGND VGND VPWR VPWR sky130_fd_sc_hd__fill_1
XFILLER_5_564 VGND VGND VPWR VPWR sky130_fd_sc_hd__decap_3
XFILLER_107_492 VGND VGND VPWR VPWR sky130_fd_sc_hd__decap_3
XFILLER_110_613 VGND VGND VPWR VPWR sky130_fd_sc_hd__decap_3
XFILLER_68_516 VGND VGND VPWR VPWR sky130_fd_sc_hd__decap_3
XFILLER_95_302 VGND VGND VPWR VPWR sky130_fd_sc_hd__decap_3
XFILLER_110_657 VGND VGND VPWR VPWR sky130_fd_sc_hd__decap_3
XFILLER_95_346 VGND VGND VPWR VPWR sky130_fd_sc_hd__decap_3
XFILLER_76_560 VGND VGND VPWR VPWR sky130_fd_sc_hd__decap_3
XFILLER_36_424 VGND VGND VPWR VPWR sky130_fd_sc_hd__fill_2
XFILLER_63_243 VGND VGND VPWR VPWR sky130_fd_sc_hd__decap_3
XFILLER_17_671 VGND VGND VPWR VPWR sky130_fd_sc_hd__fill_1
XFILLER_23_129 VGND VGND VPWR VPWR sky130_fd_sc_hd__decap_3
XFILLER_51_405 VGND VGND VPWR VPWR sky130_fd_sc_hd__decap_3
XFILLER_63_287 VGND VGND VPWR VPWR sky130_fd_sc_hd__decap_3
X_4981_ _6992_/Q _5001_/A VGND VGND VPWR VPWR _6992_/D sky130_fd_sc_hd__xor2_2
XFILLER_16_181 VGND VGND VPWR VPWR sky130_fd_sc_hd__decap_3
Xclkbuf_leaf_43_clk clkbuf_3_0__f_clk/X VGND VGND VPWR VPWR clkload8/A sky130_fd_sc_hd__clkbuf_16
Xplace298 _3651_/Y VGND VGND VPWR VPWR _3886_/B1 sky130_fd_sc_hd__buf_2
Xplace287 _3878_/A2 VGND VGND VPWR VPWR _3889_/B1 sky130_fd_sc_hd__buf_2
Xplace276 _3892_/A2 VGND VGND VPWR VPWR _3879_/A2 sky130_fd_sc_hd__buf_2
Xplace265 _5660_/A VGND VGND VPWR VPWR _3923_/A1 sky130_fd_sc_hd__buf_2
X_6720_ _6975_/CLK _6720_/D VGND VGND VPWR VPWR _6720_/Q sky130_fd_sc_hd__dfxtp_2
XTAP_TAPCELL_ROW_34_658 VGND VPWR sky130_fd_sc_hd__tapvpwrvgnd_1
XFILLER_32_663 VGND VGND VPWR VPWR sky130_fd_sc_hd__decap_3
X_6651_ _6651_/A VGND VGND VPWR VPWR _6651_/Y sky130_fd_sc_hd__inv_2
X_3863_ _6697_/Q _3925_/A2 _3925_/B1 _6875_/Q _3862_/X VGND VGND VPWR VPWR _3863_/X
+ sky130_fd_sc_hd__a221o_2
XFILLER_31_184 VGND VGND VPWR VPWR sky130_fd_sc_hd__decap_3
X_6582_ _6675_/A VGND VGND VPWR VPWR _6582_/Y sky130_fd_sc_hd__inv_2
X_5602_ _5602_/A _5634_/B VGND VGND VPWR VPWR _7026_/D sky130_fd_sc_hd__and2_2
X_3794_ _6774_/Q _3879_/A2 _3889_/A2 _6762_/Q _3793_/X VGND VGND VPWR VPWR _3794_/X
+ sky130_fd_sc_hd__a221o_2
XFILLER_11_18 VGND VGND VPWR VPWR sky130_fd_sc_hd__decap_3
XFILLER_105_429 VGND VGND VPWR VPWR sky130_fd_sc_hd__decap_3
X_7203_ _7267_/CLK _7203_/D _6483_/Y VGND VGND VPWR VPWR _7203_/Q sky130_fd_sc_hd__dfrtp_2
X_4415_ _7400_/Q _4419_/B1 _4434_/B1 _7144_/Q _4414_/X VGND VGND VPWR VPWR _4415_/X
+ sky130_fd_sc_hd__a221o_2
XFILLER_113_440 VGND VGND VPWR VPWR sky130_fd_sc_hd__decap_3
X_7134_ _7358_/CLK _7134_/D _6414_/Y VGND VGND VPWR VPWR _7134_/Q sky130_fd_sc_hd__dfrtp_2
X_4346_ _7321_/Q _4471_/S _4346_/B1 _7353_/Q VGND VGND VPWR VPWR _4346_/X sky130_fd_sc_hd__a22o_2
XFILLER_113_473 VGND VGND VPWR VPWR sky130_fd_sc_hd__decap_3
XFILLER_59_505 VGND VGND VPWR VPWR sky130_fd_sc_hd__decap_3
XTAP_TAPCELL_ROW_6_328 VGND VPWR sky130_fd_sc_hd__tapvpwrvgnd_1
XFILLER_99_685 VGND VGND VPWR VPWR sky130_fd_sc_hd__decap_3
XFILLER_98_162 VGND VGND VPWR VPWR sky130_fd_sc_hd__decap_3
XFILLER_101_657 VGND VGND VPWR VPWR sky130_fd_sc_hd__decap_3
X_7065_ clkload9/A _7065_/D _6345_/Y VGND VGND VPWR VPWR _7065_/Q sky130_fd_sc_hd__dfrtp_2
X_4277_ _5003_/A _4620_/C VGND VGND VPWR VPWR _4277_/Y sky130_fd_sc_hd__nor2_2
XFILLER_98_195 VGND VGND VPWR VPWR sky130_fd_sc_hd__fill_1
XFILLER_101_679 VGND VGND VPWR VPWR sky130_fd_sc_hd__decap_3
XFILLER_27_402 VGND VGND VPWR VPWR sky130_fd_sc_hd__decap_3
XFILLER_39_240 VGND VGND VPWR VPWR sky130_fd_sc_hd__decap_3
XFILLER_86_368 VGND VGND VPWR VPWR sky130_fd_sc_hd__decap_3
XFILLER_36_15 VGND VGND VPWR VPWR sky130_fd_sc_hd__decap_3
XFILLER_36_37 VGND VGND VPWR VPWR sky130_fd_sc_hd__decap_3
XFILLER_54_243 VGND VGND VPWR VPWR sky130_fd_sc_hd__decap_3
XFILLER_82_563 VGND VGND VPWR VPWR sky130_fd_sc_hd__decap_3
XFILLER_54_265 VGND VGND VPWR VPWR sky130_fd_sc_hd__decap_3
XTAP_TAPCELL_ROW_68_1066 VGND VPWR sky130_fd_sc_hd__tapvpwrvgnd_1
XFILLER_14_129 VGND VGND VPWR VPWR sky130_fd_sc_hd__decap_3
XFILLER_54_298 VGND VGND VPWR VPWR sky130_fd_sc_hd__decap_3
Xclkbuf_leaf_34_clk clkbuf_3_0__f_clk/X VGND VGND VPWR VPWR clkload4/A sky130_fd_sc_hd__clkbuf_16
X_6918_ _6931_/CLK _6918_/D VGND VGND VPWR VPWR _6918_/Q sky130_fd_sc_hd__dfxtp_2
XTAP_TAPCELL_ROW_81_1222 VGND VPWR sky130_fd_sc_hd__tapvpwrvgnd_1
X_6849_ _6964_/CLK _6849_/D VGND VGND VPWR VPWR _6849_/Q sky130_fd_sc_hd__dfxtp_2
XFILLER_22_184 VGND VGND VPWR VPWR sky130_fd_sc_hd__decap_3
XFILLER_108_223 VGND VGND VPWR VPWR sky130_fd_sc_hd__decap_3
XFILLER_108_256 VGND VGND VPWR VPWR sky130_fd_sc_hd__decap_3
XFILLER_108_289 VGND VGND VPWR VPWR sky130_fd_sc_hd__decap_3
XFILLER_2_512 VGND VGND VPWR VPWR sky130_fd_sc_hd__fill_2
XTAP_TAPCELL_ROW_79_1195 VGND VPWR sky130_fd_sc_hd__tapvpwrvgnd_1
XFILLER_104_440 VGND VGND VPWR VPWR sky130_fd_sc_hd__fill_1
XFILLER_7_3 VGND VGND VPWR VPWR sky130_fd_sc_hd__decap_3
XFILLER_89_140 VGND VGND VPWR VPWR sky130_fd_sc_hd__decap_3
XTAP_TAPCELL_ROW_92_1351 VGND VPWR sky130_fd_sc_hd__tapvpwrvgnd_1
XFILLER_104_462 VGND VGND VPWR VPWR sky130_fd_sc_hd__decap_3
XFILLER_2_567 VGND VGND VPWR VPWR sky130_fd_sc_hd__decap_3
XFILLER_77_33 VGND VGND VPWR VPWR sky130_fd_sc_hd__decap_3
XFILLER_89_162 VGND VGND VPWR VPWR sky130_fd_sc_hd__decap_3
XFILLER_77_335 VGND VGND VPWR VPWR sky130_fd_sc_hd__fill_1
XFILLER_77_66 VGND VGND VPWR VPWR sky130_fd_sc_hd__decap_3
XFILLER_77_357 VGND VGND VPWR VPWR sky130_fd_sc_hd__fill_1
XFILLER_77_379 VGND VGND VPWR VPWR sky130_fd_sc_hd__decap_3
XFILLER_100_690 VGND VGND VPWR VPWR sky130_fd_sc_hd__fill_2
XFILLER_92_327 VGND VGND VPWR VPWR sky130_fd_sc_hd__decap_3
XFILLER_93_21 VGND VGND VPWR VPWR sky130_fd_sc_hd__decap_3
XFILLER_45_243 VGND VGND VPWR VPWR sky130_fd_sc_hd__decap_3
XFILLER_93_54 VGND VGND VPWR VPWR sky130_fd_sc_hd__fill_2
Xhold1080 _7218_/Q VGND VGND VPWR VPWR _5221_/A sky130_fd_sc_hd__dlygate4sd3_1
Xhold1091 _7275_/Q VGND VGND VPWR VPWR _4772_/A0 sky130_fd_sc_hd__dlygate4sd3_1
XFILLER_45_287 VGND VGND VPWR VPWR sky130_fd_sc_hd__decap_3
XFILLER_93_76 VGND VGND VPWR VPWR sky130_fd_sc_hd__decap_3
XFILLER_93_87 VGND VGND VPWR VPWR sky130_fd_sc_hd__fill_2
XFILLER_14_630 VGND VGND VPWR VPWR sky130_fd_sc_hd__decap_3
XFILLER_26_70 VGND VGND VPWR VPWR sky130_fd_sc_hd__decap_3
XFILLER_33_438 VGND VGND VPWR VPWR sky130_fd_sc_hd__decap_3
XFILLER_33_449 VGND VGND VPWR VPWR sky130_fd_sc_hd__decap_3
Xclkbuf_leaf_25_clk clkload1/A VGND VGND VPWR VPWR _6976_/CLK sky130_fd_sc_hd__clkbuf_16
XFILLER_60_279 VGND VGND VPWR VPWR sky130_fd_sc_hd__decap_3
XFILLER_13_162 VGND VGND VPWR VPWR sky130_fd_sc_hd__decap_3
XTAP_TAPCELL_ROW_31_628 VGND VPWR sky130_fd_sc_hd__tapvpwrvgnd_1
XFILLER_9_133 VGND VGND VPWR VPWR sky130_fd_sc_hd__decap_3
XFILLER_42_80 VGND VGND VPWR VPWR sky130_fd_sc_hd__decap_3
XFILLER_61_6 VGND VGND VPWR VPWR sky130_fd_sc_hd__decap_3
XTAP_TAPCELL_ROW_11_385 VGND VPWR sky130_fd_sc_hd__tapvpwrvgnd_1
XFILLER_114_215 VGND VGND VPWR VPWR sky130_fd_sc_hd__decap_3
XFILLER_114_248 VGND VGND VPWR VPWR sky130_fd_sc_hd__decap_3
X_4200_ _4950_/A _4381_/A VGND VGND VPWR VPWR _4200_/X sky130_fd_sc_hd__or2_2
XFILLER_3_30 VGND VGND VPWR VPWR sky130_fd_sc_hd__decap_3
XFILLER_110_421 VGND VGND VPWR VPWR sky130_fd_sc_hd__decap_3
XFILLER_3_63 VGND VGND VPWR VPWR sky130_fd_sc_hd__decap_3
XFILLER_68_346 VGND VGND VPWR VPWR sky130_fd_sc_hd__decap_3
X_4131_ _7267_/Q _4422_/A2 _4128_/X _4130_/X VGND VGND VPWR VPWR _4131_/X sky130_fd_sc_hd__a211o_2
XFILLER_110_465 VGND VGND VPWR VPWR sky130_fd_sc_hd__decap_3
XFILLER_3_96 VGND VGND VPWR VPWR sky130_fd_sc_hd__decap_3
XFILLER_56_508 VGND VGND VPWR VPWR sky130_fd_sc_hd__decap_3
XFILLER_68_368 VGND VGND VPWR VPWR sky130_fd_sc_hd__decap_3
XFILLER_96_677 VGND VGND VPWR VPWR sky130_fd_sc_hd__decap_3
X_4062_ _7026_/Q _4437_/A2 _3945_/S _7212_/Q _4061_/X VGND VGND VPWR VPWR _4062_/X
+ sky130_fd_sc_hd__a221o_2
XTAP_TAPCELL_ROW_39_717 VGND VPWR sky130_fd_sc_hd__tapvpwrvgnd_1
XFILLER_110_498 VGND VGND VPWR VPWR sky130_fd_sc_hd__decap_3
XFILLER_83_349 VGND VGND VPWR VPWR sky130_fd_sc_hd__decap_3
XFILLER_95_187 VGND VGND VPWR VPWR sky130_fd_sc_hd__decap_3
XFILLER_24_405 VGND VGND VPWR VPWR sky130_fd_sc_hd__decap_3
XFILLER_36_287 VGND VGND VPWR VPWR sky130_fd_sc_hd__decap_3
XFILLER_51_202 VGND VGND VPWR VPWR sky130_fd_sc_hd__decap_3
XFILLER_51_213 VGND VGND VPWR VPWR sky130_fd_sc_hd__fill_1
XFILLER_91_371 VGND VGND VPWR VPWR sky130_fd_sc_hd__decap_3
XTAP_TAPCELL_ROW_19_474 VGND VPWR sky130_fd_sc_hd__tapvpwrvgnd_1
Xclkbuf_leaf_16_clk clkload3/A VGND VGND VPWR VPWR _7372_/CLK sky130_fd_sc_hd__clkbuf_16
X_4964_ _4606_/Y _4961_/X _6994_/D _4997_/A1 VGND VGND VPWR VPWR _4964_/X sky130_fd_sc_hd__a22o_2
XTAP_TAPCELL_ROW_19_485 VGND VPWR sky130_fd_sc_hd__tapvpwrvgnd_1
XFILLER_51_279 VGND VGND VPWR VPWR sky130_fd_sc_hd__fill_1
X_6703_ _7387_/CLK _6703_/D VGND VGND VPWR VPWR _6703_/Q sky130_fd_sc_hd__dfxtp_2
X_3915_ _3915_/A0 _3914_/X _5138_/S VGND VGND VPWR VPWR _7378_/D sky130_fd_sc_hd__mux2_2
X_4895_ _6997_/Q _5605_/B _4909_/B VGND VGND VPWR VPWR _4896_/B sky130_fd_sc_hd__a21o_2
X_6634_ _6634_/A VGND VGND VPWR VPWR _6634_/Y sky130_fd_sc_hd__inv_2
X_3846_ _6964_/Q _3906_/A2 _3886_/B1 _6952_/Q VGND VGND VPWR VPWR _3846_/X sky130_fd_sc_hd__a22o_2
XFILLER_20_688 VGND VGND VPWR VPWR sky130_fd_sc_hd__decap_3
X_6565_ _6599_/A VGND VGND VPWR VPWR _6565_/Y sky130_fd_sc_hd__inv_2
X_3777_ _6972_/Q _3906_/B1 _3892_/B1 _6722_/Q _3776_/X VGND VGND VPWR VPWR _3777_/X
+ sky130_fd_sc_hd__a221o_2
X_6496_ _6562_/A VGND VGND VPWR VPWR _6496_/Y sky130_fd_sc_hd__inv_2
XTAP_TAPCELL_ROW_115_1627 VGND VPWR sky130_fd_sc_hd__tapvpwrvgnd_1
XFILLER_105_204 VGND VGND VPWR VPWR sky130_fd_sc_hd__fill_1
XFILLER_105_237 VGND VGND VPWR VPWR sky130_fd_sc_hd__decap_3
Xoutput496 _3525_/A VGND VGND VPWR VPWR instruction_out[13] sky130_fd_sc_hd__clkdlybuf4s25_1
Xoutput485 _5654_/Y VGND VGND VPWR VPWR alu_result_out[31] sky130_fd_sc_hd__clkdlybuf4s25_1
Xoutput474 _5656_/B VGND VGND VPWR VPWR alu_result_out[21] sky130_fd_sc_hd__clkdlybuf4s25_1
Xoutput463 _5662_/B VGND VGND VPWR VPWR alu_result_out[11] sky130_fd_sc_hd__clkdlybuf4s25_1
XFILLER_99_471 VGND VGND VPWR VPWR sky130_fd_sc_hd__decap_3
XFILLER_101_432 VGND VGND VPWR VPWR sky130_fd_sc_hd__decap_3
XFILLER_113_281 VGND VGND VPWR VPWR sky130_fd_sc_hd__decap_3
XFILLER_59_346 VGND VGND VPWR VPWR sky130_fd_sc_hd__decap_3
XFILLER_86_121 VGND VGND VPWR VPWR sky130_fd_sc_hd__decap_3
X_7117_ _7372_/CLK _7117_/D _6397_/Y VGND VGND VPWR VPWR _7117_/Q sky130_fd_sc_hd__dfrtp_2
X_4329_ _4362_/C _4362_/A _4362_/B VGND VGND VPWR VPWR _4330_/B sky130_fd_sc_hd__and3b_2
XFILLER_101_465 VGND VGND VPWR VPWR sky130_fd_sc_hd__decap_3
XFILLER_47_36 VGND VGND VPWR VPWR sky130_fd_sc_hd__decap_3
XFILLER_86_165 VGND VGND VPWR VPWR sky130_fd_sc_hd__fill_1
XFILLER_87_666 VGND VGND VPWR VPWR sky130_fd_sc_hd__decap_3
XFILLER_87_688 VGND VGND VPWR VPWR sky130_fd_sc_hd__decap_3
X_7048_ _7403_/CLK _7048_/D _6328_/Y VGND VGND VPWR VPWR _7048_/Q sky130_fd_sc_hd__dfrtp_2
XFILLER_101_498 VGND VGND VPWR VPWR sky130_fd_sc_hd__decap_3
XFILLER_47_69 VGND VGND VPWR VPWR sky130_fd_sc_hd__decap_3
XFILLER_86_176 VGND VGND VPWR VPWR sky130_fd_sc_hd__decap_3
XPHY_EDGE_ROW_114_Right_114 VGND VGND VPWR VPWR sky130_fd_sc_hd__decap_3
XFILLER_103_42 VGND VGND VPWR VPWR sky130_fd_sc_hd__decap_3
XFILLER_55_552 VGND VGND VPWR VPWR sky130_fd_sc_hd__decap_3
XFILLER_103_75 VGND VGND VPWR VPWR sky130_fd_sc_hd__decap_3
XFILLER_27_254 VGND VGND VPWR VPWR sky130_fd_sc_hd__decap_3
XFILLER_63_24 VGND VGND VPWR VPWR sky130_fd_sc_hd__decap_3
XFILLER_82_360 VGND VGND VPWR VPWR sky130_fd_sc_hd__decap_3
XFILLER_82_371 VGND VGND VPWR VPWR sky130_fd_sc_hd__decap_3
XFILLER_15_449 VGND VGND VPWR VPWR sky130_fd_sc_hd__fill_2
XFILLER_27_287 VGND VGND VPWR VPWR sky130_fd_sc_hd__decap_3
XFILLER_42_224 VGND VGND VPWR VPWR sky130_fd_sc_hd__decap_3
XFILLER_63_57 VGND VGND VPWR VPWR sky130_fd_sc_hd__decap_3
XFILLER_70_522 VGND VGND VPWR VPWR sky130_fd_sc_hd__fill_2
XFILLER_30_408 VGND VGND VPWR VPWR sky130_fd_sc_hd__fill_2
XFILLER_42_268 VGND VGND VPWR VPWR sky130_fd_sc_hd__decap_3
XFILLER_10_132 VGND VGND VPWR VPWR sky130_fd_sc_hd__decap_3
XFILLER_7_604 VGND VGND VPWR VPWR sky130_fd_sc_hd__decap_3
XFILLER_7_615 VGND VGND VPWR VPWR sky130_fd_sc_hd__fill_1
XFILLER_6_103 VGND VGND VPWR VPWR sky130_fd_sc_hd__decap_3
XFILLER_109_554 VGND VGND VPWR VPWR sky130_fd_sc_hd__decap_3
XFILLER_12_50 VGND VGND VPWR VPWR sky130_fd_sc_hd__decap_3
XFILLER_6_136 VGND VGND VPWR VPWR sky130_fd_sc_hd__decap_3
XFILLER_6_147 VGND VGND VPWR VPWR sky130_fd_sc_hd__decap_3
Xwire568 _3383_/Y VGND VGND VPWR VPWR _4505_/S sky130_fd_sc_hd__clkbuf_4
XFILLER_88_32 VGND VGND VPWR VPWR sky130_fd_sc_hd__fill_1
XFILLER_88_43 VGND VGND VPWR VPWR sky130_fd_sc_hd__decap_3
XFILLER_88_76 VGND VGND VPWR VPWR sky130_fd_sc_hd__decap_3
XFILLER_2_386 VGND VGND VPWR VPWR sky130_fd_sc_hd__decap_3
XFILLER_77_110 VGND VGND VPWR VPWR sky130_fd_sc_hd__fill_2
XFILLER_26_9 VGND VGND VPWR VPWR sky130_fd_sc_hd__decap_3
XFILLER_65_305 VGND VGND VPWR VPWR sky130_fd_sc_hd__decap_3
XFILLER_77_176 VGND VGND VPWR VPWR sky130_fd_sc_hd__fill_1
XFILLER_77_187 VGND VGND VPWR VPWR sky130_fd_sc_hd__decap_3
XFILLER_93_625 VGND VGND VPWR VPWR sky130_fd_sc_hd__fill_1
XFILLER_93_647 VGND VGND VPWR VPWR sky130_fd_sc_hd__decap_3
XFILLER_18_221 VGND VGND VPWR VPWR sky130_fd_sc_hd__decap_3
XFILLER_46_530 VGND VGND VPWR VPWR sky130_fd_sc_hd__fill_2
XFILLER_58_390 VGND VGND VPWR VPWR sky130_fd_sc_hd__fill_2
XFILLER_65_349 VGND VGND VPWR VPWR sky130_fd_sc_hd__decap_3
XFILLER_92_135 VGND VGND VPWR VPWR sky130_fd_sc_hd__decap_3
XFILLER_33_202 VGND VGND VPWR VPWR sky130_fd_sc_hd__decap_3
XFILLER_61_588 VGND VGND VPWR VPWR sky130_fd_sc_hd__decap_3
XTAP_TAPCELL_ROW_44_775 VGND VPWR sky130_fd_sc_hd__tapvpwrvgnd_1
XTAP_TAPCELL_ROW_16_444 VGND VPWR sky130_fd_sc_hd__tapvpwrvgnd_1
X_3700_ _6939_/Q _3902_/A2 _3759_/A2 _6803_/Q _3699_/X VGND VGND VPWR VPWR _3700_/X
+ sky130_fd_sc_hd__a221o_2
XFILLER_41_290 VGND VGND VPWR VPWR sky130_fd_sc_hd__decap_3
X_4680_ _4680_/A _5015_/B VGND VGND VPWR VPWR _5009_/A sky130_fd_sc_hd__nor2_2
X_3631_ _3630_/A _3630_/B _5146_/B1 VGND VGND VPWR VPWR _3631_/Y sky130_fd_sc_hd__o21ai_2
X_6350_ _6540_/A VGND VGND VPWR VPWR _6350_/Y sky130_fd_sc_hd__inv_2
X_3562_ _4532_/S _3562_/B _3561_/X VGND VGND VPWR VPWR _5362_/C sky130_fd_sc_hd__or3b_2
XFILLER_115_502 VGND VGND VPWR VPWR sky130_fd_sc_hd__fill_2
XFILLER_6_681 VGND VGND VPWR VPWR sky130_fd_sc_hd__decap_3
XFILLER_115_557 VGND VGND VPWR VPWR sky130_fd_sc_hd__decap_3
XFILLER_5_191 VGND VGND VPWR VPWR sky130_fd_sc_hd__decap_3
X_6281_ _6285_/A VGND VGND VPWR VPWR _6281_/Y sky130_fd_sc_hd__inv_2
X_3493_ _7087_/Q _4321_/A2 _3407_/X _7119_/Q VGND VGND VPWR VPWR _3493_/X sky130_fd_sc_hd__a22o_2
XFILLER_115_579 VGND VGND VPWR VPWR sky130_fd_sc_hd__decap_3
XFILLER_88_419 VGND VGND VPWR VPWR sky130_fd_sc_hd__fill_1
Xclkbuf_leaf_5_clk clkload2/A VGND VGND VPWR VPWR _7266_/CLK sky130_fd_sc_hd__clkbuf_16
X_5232_ _5232_/A0 _4716_/X _5245_/S VGND VGND VPWR VPWR _7214_/D sky130_fd_sc_hd__mux2_2
XFILLER_69_633 VGND VGND VPWR VPWR sky130_fd_sc_hd__decap_3
XFILLER_69_644 VGND VGND VPWR VPWR sky130_fd_sc_hd__decap_3
X_5163_ _5163_/A _5182_/B VGND VGND VPWR VPWR _7246_/D sky130_fd_sc_hd__and2_2
XFILLER_110_251 VGND VGND VPWR VPWR sky130_fd_sc_hd__fill_1
XFILLER_29_519 VGND VGND VPWR VPWR sky130_fd_sc_hd__decap_3
XFILLER_69_666 VGND VGND VPWR VPWR sky130_fd_sc_hd__fill_2
XFILLER_69_688 VGND VGND VPWR VPWR sky130_fd_sc_hd__decap_3
X_4114_ _7172_/Q _4459_/C1 _4348_/B1 _7140_/Q _4113_/X VGND VGND VPWR VPWR _4114_/X
+ sky130_fd_sc_hd__a221o_2
XTAP_TAPCELL_ROW_110_1568 VGND VPWR sky130_fd_sc_hd__tapvpwrvgnd_1
XFILLER_68_165 VGND VGND VPWR VPWR sky130_fd_sc_hd__decap_3
XFILLER_83_113 VGND VGND VPWR VPWR sky130_fd_sc_hd__decap_3
X_5094_ _5666_/A _6986_/D _5093_/X VGND VGND VPWR VPWR _5094_/X sky130_fd_sc_hd__a21o_2
XFILLER_37_530 VGND VGND VPWR VPWR sky130_fd_sc_hd__decap_3
XFILLER_56_349 VGND VGND VPWR VPWR sky130_fd_sc_hd__decap_3
XFILLER_83_146 VGND VGND VPWR VPWR sky130_fd_sc_hd__decap_3
X_4045_ _7085_/Q _4432_/A2 _4142_/A _4044_/X VGND VGND VPWR VPWR _4054_/A sky130_fd_sc_hd__o211a_2
XFILLER_17_39 VGND VGND VPWR VPWR sky130_fd_sc_hd__decap_3
XFILLER_37_585 VGND VGND VPWR VPWR sky130_fd_sc_hd__decap_3
XFILLER_64_371 VGND VGND VPWR VPWR sky130_fd_sc_hd__decap_3
XFILLER_24_224 VGND VGND VPWR VPWR sky130_fd_sc_hd__fill_1
XFILLER_52_522 VGND VGND VPWR VPWR sky130_fd_sc_hd__fill_2
XTAP_TAPCELL_ROW_65_1036 VGND VPWR sky130_fd_sc_hd__tapvpwrvgnd_1
XFILLER_12_419 VGND VGND VPWR VPWR sky130_fd_sc_hd__fill_1
XFILLER_24_268 VGND VGND VPWR VPWR sky130_fd_sc_hd__decap_3
XFILLER_20_430 VGND VGND VPWR VPWR sky130_fd_sc_hd__fill_1
X_4878_ _4997_/A1 _6999_/D _4870_/Y _4877_/X VGND VGND VPWR VPWR _4878_/X sky130_fd_sc_hd__a211o_2
X_6617_ _6617_/A VGND VGND VPWR VPWR _6617_/Y sky130_fd_sc_hd__inv_2
X_3829_ _6908_/Q _3884_/A2 _3912_/B1 _6900_/Q VGND VGND VPWR VPWR _3829_/X sky130_fd_sc_hd__a22o_2
XFILLER_106_524 VGND VGND VPWR VPWR sky130_fd_sc_hd__decap_3
X_6548_ _6548_/A VGND VGND VPWR VPWR _6548_/Y sky130_fd_sc_hd__inv_2
XFILLER_109_6 VGND VGND VPWR VPWR sky130_fd_sc_hd__decap_3
XFILLER_3_128 VGND VGND VPWR VPWR sky130_fd_sc_hd__decap_3
X_6479_ _6642_/A VGND VGND VPWR VPWR _6479_/Y sky130_fd_sc_hd__inv_2
XTAP_TAPCELL_ROW_76_1165 VGND VPWR sky130_fd_sc_hd__tapvpwrvgnd_1
XFILLER_79_408 VGND VGND VPWR VPWR sky130_fd_sc_hd__decap_3
XFILLER_58_35 VGND VGND VPWR VPWR sky130_fd_sc_hd__decap_3
XFILLER_87_430 VGND VGND VPWR VPWR sky130_fd_sc_hd__decap_3
XFILLER_99_290 VGND VGND VPWR VPWR sky130_fd_sc_hd__decap_3
XFILLER_59_132 VGND VGND VPWR VPWR sky130_fd_sc_hd__fill_1
XFILLER_101_273 VGND VGND VPWR VPWR sky130_fd_sc_hd__fill_2
XFILLER_114_41 VGND VGND VPWR VPWR sky130_fd_sc_hd__decap_3
XFILLER_47_327 VGND VGND VPWR VPWR sky130_fd_sc_hd__fill_2
XFILLER_59_187 VGND VGND VPWR VPWR sky130_fd_sc_hd__decap_3
XFILLER_87_474 VGND VGND VPWR VPWR sky130_fd_sc_hd__fill_1
XFILLER_114_74 VGND VGND VPWR VPWR sky130_fd_sc_hd__decap_3
XFILLER_114_85 VGND VGND VPWR VPWR sky130_fd_sc_hd__decap_3
XFILLER_28_530 VGND VGND VPWR VPWR sky130_fd_sc_hd__fill_2
XFILLER_74_124 VGND VGND VPWR VPWR sky130_fd_sc_hd__decap_3
XFILLER_74_23 VGND VGND VPWR VPWR sky130_fd_sc_hd__decap_3
XFILLER_15_202 VGND VGND VPWR VPWR sky130_fd_sc_hd__decap_3
XFILLER_74_56 VGND VGND VPWR VPWR sky130_fd_sc_hd__decap_3
XFILLER_74_67 VGND VGND VPWR VPWR sky130_fd_sc_hd__decap_3
XFILLER_55_382 VGND VGND VPWR VPWR sky130_fd_sc_hd__fill_1
XFILLER_55_393 VGND VGND VPWR VPWR sky130_fd_sc_hd__fill_1
XTAP_TAPCELL_ROW_87_1294 VGND VPWR sky130_fd_sc_hd__tapvpwrvgnd_1
XFILLER_90_11 VGND VGND VPWR VPWR sky130_fd_sc_hd__decap_3
XFILLER_15_279 VGND VGND VPWR VPWR sky130_fd_sc_hd__fill_1
XFILLER_30_227 VGND VGND VPWR VPWR sky130_fd_sc_hd__decap_3
XTAP_TAPCELL_ROW_13_403 VGND VPWR sky130_fd_sc_hd__tapvpwrvgnd_1
XFILLER_30_249 VGND VGND VPWR VPWR sky130_fd_sc_hd__decap_3
XFILLER_90_88 VGND VGND VPWR VPWR sky130_fd_sc_hd__decap_3
XTAP_TAPCELL_ROW_41_745 VGND VPWR sky130_fd_sc_hd__tapvpwrvgnd_1
XFILLER_23_60 VGND VGND VPWR VPWR sky130_fd_sc_hd__decap_3
XFILLER_99_75 VGND VGND VPWR VPWR sky130_fd_sc_hd__decap_3
XFILLER_3_662 VGND VGND VPWR VPWR sky130_fd_sc_hd__decap_3
XFILLER_3_673 VGND VGND VPWR VPWR sky130_fd_sc_hd__decap_3
XFILLER_112_527 VGND VGND VPWR VPWR sky130_fd_sc_hd__decap_3
XFILLER_2_150 VGND VGND VPWR VPWR sky130_fd_sc_hd__decap_3
XFILLER_78_430 VGND VGND VPWR VPWR sky130_fd_sc_hd__decap_3
XFILLER_97_249 VGND VGND VPWR VPWR sky130_fd_sc_hd__decap_3
XFILLER_38_327 VGND VGND VPWR VPWR sky130_fd_sc_hd__fill_2
XFILLER_65_113 VGND VGND VPWR VPWR sky130_fd_sc_hd__decap_3
XFILLER_66_625 VGND VGND VPWR VPWR sky130_fd_sc_hd__decap_3
XFILLER_78_474 VGND VGND VPWR VPWR sky130_fd_sc_hd__fill_2
XFILLER_93_411 VGND VGND VPWR VPWR sky130_fd_sc_hd__fill_2
XFILLER_93_422 VGND VGND VPWR VPWR sky130_fd_sc_hd__fill_1
XTAP_TAPCELL_ROW_49_834 VGND VPWR sky130_fd_sc_hd__tapvpwrvgnd_1
XFILLER_38_349 VGND VGND VPWR VPWR sky130_fd_sc_hd__decap_3
XFILLER_65_135 VGND VGND VPWR VPWR sky130_fd_sc_hd__decap_3
XFILLER_66_669 VGND VGND VPWR VPWR sky130_fd_sc_hd__decap_3
XFILLER_93_444 VGND VGND VPWR VPWR sky130_fd_sc_hd__fill_1
XTAP_TAPCELL_ROW_49_845 VGND VPWR sky130_fd_sc_hd__tapvpwrvgnd_1
XFILLER_0_53 VGND VGND VPWR VPWR sky130_fd_sc_hd__decap_3
XFILLER_81_617 VGND VGND VPWR VPWR sky130_fd_sc_hd__decap_3
XFILLER_34_522 VGND VGND VPWR VPWR sky130_fd_sc_hd__fill_2
XFILLER_34_533 VGND VGND VPWR VPWR sky130_fd_sc_hd__fill_1
XFILLER_80_127 VGND VGND VPWR VPWR sky130_fd_sc_hd__decap_3
XFILLER_21_205 VGND VGND VPWR VPWR sky130_fd_sc_hd__decap_3
XFILLER_61_396 VGND VGND VPWR VPWR sky130_fd_sc_hd__decap_3
X_4801_ _4801_/A _4801_/B VGND VGND VPWR VPWR _7003_/D sky130_fd_sc_hd__nor2_2
XFILLER_14_290 VGND VGND VPWR VPWR sky130_fd_sc_hd__decap_3
XFILLER_21_249 VGND VGND VPWR VPWR sky130_fd_sc_hd__decap_3
XFILLER_9_51 VGND VGND VPWR VPWR sky130_fd_sc_hd__decap_3
X_4663_ _4764_/B _4040_/B _4608_/Y _4659_/X _4662_/Y VGND VGND VPWR VPWR _5665_/A
+ sky130_fd_sc_hd__o32a_2
XFILLER_9_84 VGND VGND VPWR VPWR sky130_fd_sc_hd__decap_3
X_6402_ _6532_/A VGND VGND VPWR VPWR _6402_/Y sky130_fd_sc_hd__inv_2
X_3614_ _3614_/A _3614_/B VGND VGND VPWR VPWR _3746_/B sky130_fd_sc_hd__and2_2
X_7382_ _7384_/CLK _7382_/D _6662_/Y VGND VGND VPWR VPWR _7382_/Q sky130_fd_sc_hd__dfrtp_2
Xhold902 _7088_/Q VGND VGND VPWR VPWR _7088_/D sky130_fd_sc_hd__dlygate4sd3_1
Xhold913 _6698_/Q VGND VGND VPWR VPWR hold913/X sky130_fd_sc_hd__dlygate4sd3_1
XFILLER_115_343 VGND VGND VPWR VPWR sky130_fd_sc_hd__decap_3
Xhold924 _7023_/Q VGND VGND VPWR VPWR _5609_/A sky130_fd_sc_hd__dlygate4sd3_1
Xhold935 _6694_/Q VGND VGND VPWR VPWR hold935/X sky130_fd_sc_hd__dlygate4sd3_1
Xhold946 _6691_/Q VGND VGND VPWR VPWR hold946/X sky130_fd_sc_hd__dlygate4sd3_1
X_6333_ _6682_/A VGND VGND VPWR VPWR _6333_/Y sky130_fd_sc_hd__inv_2
X_3545_ _3545_/A _3545_/B VGND VGND VPWR VPWR _3636_/A sky130_fd_sc_hd__nor2_2
XFILLER_103_505 VGND VGND VPWR VPWR sky130_fd_sc_hd__decap_3
Xhold979 _7049_/Q VGND VGND VPWR VPWR hold979/X sky130_fd_sc_hd__dlygate4sd3_1
Xhold968 _7015_/Q VGND VGND VPWR VPWR _5626_/A sky130_fd_sc_hd__dlygate4sd3_1
Xhold957 _6692_/Q VGND VGND VPWR VPWR hold957/X sky130_fd_sc_hd__dlygate4sd3_1
X_6264_ _6642_/A VGND VGND VPWR VPWR _6264_/Y sky130_fd_sc_hd__inv_2
X_3476_ _7056_/Q _3577_/B _3590_/A VGND VGND VPWR VPWR _3502_/B sky130_fd_sc_hd__o21ai_2
XFILLER_88_227 VGND VGND VPWR VPWR sky130_fd_sc_hd__decap_3
X_5215_ _7221_/Q _5225_/B VGND VGND VPWR VPWR _7221_/D sky130_fd_sc_hd__and2_2
XFILLER_111_582 VGND VGND VPWR VPWR sky130_fd_sc_hd__decap_3
XFILLER_29_305 VGND VGND VPWR VPWR sky130_fd_sc_hd__fill_1
XFILLER_57_614 VGND VGND VPWR VPWR sky130_fd_sc_hd__fill_2
X_5146_ _5145_/A _3541_/X _5146_/B1 VGND VGND VPWR VPWR _5146_/Y sky130_fd_sc_hd__o21ai_2
XFILLER_56_124 VGND VGND VPWR VPWR sky130_fd_sc_hd__decap_3
XFILLER_57_647 VGND VGND VPWR VPWR sky130_fd_sc_hd__decap_3
XFILLER_84_433 VGND VGND VPWR VPWR sky130_fd_sc_hd__decap_3
XFILLER_96_293 VGND VGND VPWR VPWR sky130_fd_sc_hd__decap_3
X_5077_ _3833_/S _3863_/X _5658_/A VGND VGND VPWR VPWR _5077_/X sky130_fd_sc_hd__a21o_2
XFILLER_56_157 VGND VGND VPWR VPWR sky130_fd_sc_hd__decap_3
XFILLER_84_466 VGND VGND VPWR VPWR sky130_fd_sc_hd__fill_2
XFILLER_84_477 VGND VGND VPWR VPWR sky130_fd_sc_hd__decap_3
XFILLER_25_511 VGND VGND VPWR VPWR sky130_fd_sc_hd__fill_2
XFILLER_25_533 VGND VGND VPWR VPWR sky130_fd_sc_hd__decap_3
XFILLER_44_15 VGND VGND VPWR VPWR sky130_fd_sc_hd__decap_3
XFILLER_65_691 VGND VGND VPWR VPWR sky130_fd_sc_hd__fill_1
XFILLER_71_138 VGND VGND VPWR VPWR sky130_fd_sc_hd__fill_2
XFILLER_52_330 VGND VGND VPWR VPWR sky130_fd_sc_hd__decap_3
XFILLER_64_190 VGND VGND VPWR VPWR sky130_fd_sc_hd__decap_3
XFILLER_100_21 VGND VGND VPWR VPWR sky130_fd_sc_hd__decap_3
XFILLER_25_588 VGND VGND VPWR VPWR sky130_fd_sc_hd__decap_3
XFILLER_40_514 VGND VGND VPWR VPWR sky130_fd_sc_hd__fill_2
XFILLER_40_536 VGND VGND VPWR VPWR sky130_fd_sc_hd__fill_2
XFILLER_80_672 VGND VGND VPWR VPWR sky130_fd_sc_hd__decap_3
XFILLER_100_32 VGND VGND VPWR VPWR sky130_fd_sc_hd__decap_3
XFILLER_40_547 VGND VGND VPWR VPWR sky130_fd_sc_hd__fill_2
XFILLER_100_65 VGND VGND VPWR VPWR sky130_fd_sc_hd__decap_3
XFILLER_60_69 VGND VGND VPWR VPWR sky130_fd_sc_hd__decap_3
XFILLER_109_30 VGND VGND VPWR VPWR sky130_fd_sc_hd__decap_3
XFILLER_109_63 VGND VGND VPWR VPWR sky130_fd_sc_hd__decap_3
XFILLER_69_12 VGND VGND VPWR VPWR sky130_fd_sc_hd__decap_3
XFILLER_106_365 VGND VGND VPWR VPWR sky130_fd_sc_hd__fill_1
XFILLER_109_96 VGND VGND VPWR VPWR sky130_fd_sc_hd__decap_3
XFILLER_69_78 VGND VGND VPWR VPWR sky130_fd_sc_hd__decap_3
XFILLER_0_654 VGND VGND VPWR VPWR sky130_fd_sc_hd__decap_3
XFILLER_94_208 VGND VGND VPWR VPWR sky130_fd_sc_hd__fill_1
XFILLER_47_113 VGND VGND VPWR VPWR sky130_fd_sc_hd__fill_2
XFILLER_48_636 VGND VGND VPWR VPWR sky130_fd_sc_hd__decap_3
XFILLER_75_411 VGND VGND VPWR VPWR sky130_fd_sc_hd__decap_3
XFILLER_85_11 VGND VGND VPWR VPWR sky130_fd_sc_hd__decap_3
XFILLER_48_669 VGND VGND VPWR VPWR sky130_fd_sc_hd__decap_3
XFILLER_75_444 VGND VGND VPWR VPWR sky130_fd_sc_hd__decap_3
XFILLER_75_455 VGND VGND VPWR VPWR sky130_fd_sc_hd__decap_3
XTAP_TAPCELL_ROW_89_1323 VGND VPWR sky130_fd_sc_hd__tapvpwrvgnd_1
XFILLER_18_71 VGND VGND VPWR VPWR sky130_fd_sc_hd__decap_3
XFILLER_47_157 VGND VGND VPWR VPWR sky130_fd_sc_hd__fill_1
XFILLER_63_617 VGND VGND VPWR VPWR sky130_fd_sc_hd__decap_3
XFILLER_75_488 VGND VGND VPWR VPWR sky130_fd_sc_hd__decap_3
XFILLER_85_99 VGND VGND VPWR VPWR sky130_fd_sc_hd__decap_3
XFILLER_90_403 VGND VGND VPWR VPWR sky130_fd_sc_hd__decap_3
XTAP_TAPCELL_ROW_46_804 VGND VPWR sky130_fd_sc_hd__tapvpwrvgnd_1
XFILLER_16_533 VGND VGND VPWR VPWR sky130_fd_sc_hd__decap_3
XFILLER_62_138 VGND VGND VPWR VPWR sky130_fd_sc_hd__fill_2
XFILLER_71_650 VGND VGND VPWR VPWR sky130_fd_sc_hd__decap_3
XFILLER_31_514 VGND VGND VPWR VPWR sky130_fd_sc_hd__fill_1
XTAP_TAPCELL_ROW_26_561 VGND VPWR sky130_fd_sc_hd__tapvpwrvgnd_1
XFILLER_43_396 VGND VGND VPWR VPWR sky130_fd_sc_hd__decap_3
XFILLER_70_193 VGND VGND VPWR VPWR sky130_fd_sc_hd__decap_3
XFILLER_93_9 VGND VGND VPWR VPWR sky130_fd_sc_hd__decap_3
XFILLER_7_231 VGND VGND VPWR VPWR sky130_fd_sc_hd__decap_3
XFILLER_116_129 VGND VGND VPWR VPWR sky130_fd_sc_hd__decap_3
XFILLER_50_91 VGND VGND VPWR VPWR sky130_fd_sc_hd__decap_3
X_3330_ _3330_/A VGND VGND VPWR VPWR _3330_/Y sky130_fd_sc_hd__inv_2
XFILLER_98_503 VGND VGND VPWR VPWR sky130_fd_sc_hd__decap_3
XFILLER_3_481 VGND VGND VPWR VPWR sky130_fd_sc_hd__decap_3
XFILLER_98_536 VGND VGND VPWR VPWR sky130_fd_sc_hd__fill_1
XFILLER_112_346 VGND VGND VPWR VPWR sky130_fd_sc_hd__decap_3
XFILLER_112_368 VGND VGND VPWR VPWR sky130_fd_sc_hd__fill_2
X_5000_ _6991_/Q _5026_/A VGND VGND VPWR VPWR _5001_/B sky130_fd_sc_hd__nor2_2
XPHY_EDGE_ROW_0_Left_117 VGND VGND VPWR VPWR sky130_fd_sc_hd__decap_3
XFILLER_98_558 VGND VGND VPWR VPWR sky130_fd_sc_hd__decap_3
XFILLER_100_519 VGND VGND VPWR VPWR sky130_fd_sc_hd__decap_3
XFILLER_22_3 VGND VGND VPWR VPWR sky130_fd_sc_hd__decap_3
XFILLER_38_102 VGND VGND VPWR VPWR sky130_fd_sc_hd__decap_3
Xsingle_cycle_cpu VGND VGND VPWR VPWR single_cycle_cpu/HI instruction_out[19] sky130_fd_sc_hd__conb_1
XFILLER_38_124 VGND VGND VPWR VPWR sky130_fd_sc_hd__decap_3
XFILLER_38_168 VGND VGND VPWR VPWR sky130_fd_sc_hd__decap_3
XFILLER_54_628 VGND VGND VPWR VPWR sky130_fd_sc_hd__decap_3
XFILLER_47_691 VGND VGND VPWR VPWR sky130_fd_sc_hd__fill_1
XFILLER_53_127 VGND VGND VPWR VPWR sky130_fd_sc_hd__decap_3
X_6951_ _6964_/CLK _6951_/D VGND VGND VPWR VPWR _6951_/Q sky130_fd_sc_hd__dfxtp_2
XFILLER_34_352 VGND VGND VPWR VPWR sky130_fd_sc_hd__decap_3
XFILLER_81_458 VGND VGND VPWR VPWR sky130_fd_sc_hd__decap_3
X_6882_ _6975_/CLK _6882_/D VGND VGND VPWR VPWR _6882_/Q sky130_fd_sc_hd__dfxtp_2
XFILLER_14_18 VGND VGND VPWR VPWR sky130_fd_sc_hd__decap_3
XFILLER_34_385 VGND VGND VPWR VPWR sky130_fd_sc_hd__fill_1
XFILLER_62_672 VGND VGND VPWR VPWR sky130_fd_sc_hd__decap_3
XFILLER_14_29 VGND VGND VPWR VPWR sky130_fd_sc_hd__decap_3
XFILLER_61_193 VGND VGND VPWR VPWR sky130_fd_sc_hd__decap_3
X_5695_ _7353_/Q hold908/X _5719_/S VGND VGND VPWR VPWR _6697_/D sky130_fd_sc_hd__mux2_2
XFILLER_30_17 VGND VGND VPWR VPWR sky130_fd_sc_hd__decap_3
X_4646_ _4646_/A _4646_/B VGND VGND VPWR VPWR _4646_/Y sky130_fd_sc_hd__nand2_2
XFILLER_107_129 VGND VGND VPWR VPWR sky130_fd_sc_hd__decap_3
XFILLER_116_641 VGND VGND VPWR VPWR sky130_fd_sc_hd__decap_3
X_7365_ _7365_/CLK _7365_/D _6645_/Y VGND VGND VPWR VPWR _7365_/Q sky130_fd_sc_hd__dfrtp_2
Xhold710 _6855_/Q VGND VGND VPWR VPWR _6855_/D sky130_fd_sc_hd__dlygate4sd3_1
Xhold721 _6936_/Q VGND VGND VPWR VPWR _6936_/D sky130_fd_sc_hd__dlygate4sd3_1
X_4577_ _4577_/A _4577_/B VGND VGND VPWR VPWR _7292_/D sky130_fd_sc_hd__and2_2
XFILLER_115_140 VGND VGND VPWR VPWR sky130_fd_sc_hd__decap_3
Xhold732 _6848_/Q VGND VGND VPWR VPWR _6848_/D sky130_fd_sc_hd__dlygate4sd3_1
Xhold743 _6779_/Q VGND VGND VPWR VPWR _6779_/D sky130_fd_sc_hd__dlygate4sd3_1
Xhold754 _6845_/Q VGND VGND VPWR VPWR _6845_/D sky130_fd_sc_hd__dlygate4sd3_1
X_6316_ _6640_/A VGND VGND VPWR VPWR _6316_/Y sky130_fd_sc_hd__inv_2
XFILLER_103_313 VGND VGND VPWR VPWR sky130_fd_sc_hd__decap_3
XFILLER_115_184 VGND VGND VPWR VPWR sky130_fd_sc_hd__decap_3
XFILLER_1_429 VGND VGND VPWR VPWR sky130_fd_sc_hd__fill_1
X_7296_ _7397_/CLK _7296_/D _6576_/Y VGND VGND VPWR VPWR _7296_/Q sky130_fd_sc_hd__dfrtp_2
Xhold765 _6851_/Q VGND VGND VPWR VPWR _6851_/D sky130_fd_sc_hd__dlygate4sd3_1
Xhold776 _6969_/Q VGND VGND VPWR VPWR _6969_/D sky130_fd_sc_hd__dlygate4sd3_1
Xhold787 _6937_/Q VGND VGND VPWR VPWR _6937_/D sky130_fd_sc_hd__dlygate4sd3_1
X_3528_ _3528_/A _5118_/D VGND VGND VPWR VPWR _5659_/A sky130_fd_sc_hd__or2_2
XTAP_TAPCELL_ROW_73_1124 VGND VPWR sky130_fd_sc_hd__tapvpwrvgnd_1
Xhold798 _6769_/Q VGND VGND VPWR VPWR _6769_/D sky130_fd_sc_hd__dlygate4sd3_1
X_3459_ _7217_/Q _4340_/A2 _4235_/B1 _7121_/Q VGND VGND VPWR VPWR _3459_/X sky130_fd_sc_hd__a22o_2
XFILLER_69_260 VGND VGND VPWR VPWR sky130_fd_sc_hd__decap_3
XFILLER_97_580 VGND VGND VPWR VPWR sky130_fd_sc_hd__fill_2
XFILLER_29_113 VGND VGND VPWR VPWR sky130_fd_sc_hd__decap_3
XFILLER_84_230 VGND VGND VPWR VPWR sky130_fd_sc_hd__decap_3
X_5129_ _5129_/A _6979_/Q VGND VGND VPWR VPWR _5130_/C sky130_fd_sc_hd__nor2_2
XFILLER_45_617 VGND VGND VPWR VPWR sky130_fd_sc_hd__decap_3
XFILLER_57_455 VGND VGND VPWR VPWR sky130_fd_sc_hd__decap_3
XFILLER_57_488 VGND VGND VPWR VPWR sky130_fd_sc_hd__decap_3
XFILLER_84_263 VGND VGND VPWR VPWR sky130_fd_sc_hd__decap_3
XFILLER_38_680 VGND VGND VPWR VPWR sky130_fd_sc_hd__decap_3
XFILLER_44_105 VGND VGND VPWR VPWR sky130_fd_sc_hd__decap_3
XFILLER_55_36 VGND VGND VPWR VPWR sky130_fd_sc_hd__decap_3
XFILLER_55_69 VGND VGND VPWR VPWR sky130_fd_sc_hd__decap_3
XFILLER_72_436 VGND VGND VPWR VPWR sky130_fd_sc_hd__decap_3
XFILLER_72_447 VGND VGND VPWR VPWR sky130_fd_sc_hd__decap_3
XFILLER_111_31 VGND VGND VPWR VPWR sky130_fd_sc_hd__decap_3
XFILLER_25_352 VGND VGND VPWR VPWR sky130_fd_sc_hd__decap_3
XFILLER_37_190 VGND VGND VPWR VPWR sky130_fd_sc_hd__decap_3
XFILLER_53_661 VGND VGND VPWR VPWR sky130_fd_sc_hd__decap_3
XFILLER_13_503 VGND VGND VPWR VPWR sky130_fd_sc_hd__fill_1
XFILLER_52_171 VGND VGND VPWR VPWR sky130_fd_sc_hd__decap_3
XFILLER_80_480 VGND VGND VPWR VPWR sky130_fd_sc_hd__fill_1
XTAP_TAPCELL_ROW_84_1264 VGND VPWR sky130_fd_sc_hd__tapvpwrvgnd_1
XFILLER_111_75 VGND VGND VPWR VPWR sky130_fd_sc_hd__decap_3
XFILLER_25_396 VGND VGND VPWR VPWR sky130_fd_sc_hd__decap_3
XFILLER_71_46 VGND VGND VPWR VPWR sky130_fd_sc_hd__decap_3
XTAP_TAPCELL_ROW_23_531 VGND VPWR sky130_fd_sc_hd__tapvpwrvgnd_1
XFILLER_13_569 VGND VGND VPWR VPWR sky130_fd_sc_hd__decap_3
XFILLER_40_377 VGND VGND VPWR VPWR sky130_fd_sc_hd__decap_3
XFILLER_71_68 VGND VGND VPWR VPWR sky130_fd_sc_hd__decap_3
XTAP_TAPCELL_ROW_51_862 VGND VPWR sky130_fd_sc_hd__tapvpwrvgnd_1
XFILLER_107_641 VGND VGND VPWR VPWR sky130_fd_sc_hd__decap_3
XFILLER_4_212 VGND VGND VPWR VPWR sky130_fd_sc_hd__decap_3
XFILLER_20_50 VGND VGND VPWR VPWR sky130_fd_sc_hd__decap_3
XFILLER_107_685 VGND VGND VPWR VPWR sky130_fd_sc_hd__decap_3
XFILLER_20_94 VGND VGND VPWR VPWR sky130_fd_sc_hd__decap_3
XTAP_TAPCELL_ROW_95_1393 VGND VPWR sky130_fd_sc_hd__tapvpwrvgnd_1
XFILLER_96_32 VGND VGND VPWR VPWR sky130_fd_sc_hd__decap_3
XFILLER_0_473 VGND VGND VPWR VPWR sky130_fd_sc_hd__decap_3
XFILLER_67_219 VGND VGND VPWR VPWR sky130_fd_sc_hd__decap_3
XFILLER_29_81 VGND VGND VPWR VPWR sky130_fd_sc_hd__decap_3
XFILLER_48_455 VGND VGND VPWR VPWR sky130_fd_sc_hd__decap_3
XFILLER_48_466 VGND VGND VPWR VPWR sky130_fd_sc_hd__decap_3
XFILLER_48_477 VGND VGND VPWR VPWR sky130_fd_sc_hd__decap_3
XTAP_TAPCELL_ROW_59_962 VGND VPWR sky130_fd_sc_hd__tapvpwrvgnd_1
XFILLER_35_116 VGND VGND VPWR VPWR sky130_fd_sc_hd__decap_3
XFILLER_36_639 VGND VGND VPWR VPWR sky130_fd_sc_hd__decap_3
XFILLER_48_499 VGND VGND VPWR VPWR sky130_fd_sc_hd__decap_3
XFILLER_63_436 VGND VGND VPWR VPWR sky130_fd_sc_hd__decap_3
XFILLER_75_296 VGND VGND VPWR VPWR sky130_fd_sc_hd__decap_3
XFILLER_90_200 VGND VGND VPWR VPWR sky130_fd_sc_hd__fill_2
Xplace403 _4532_/S VGND VGND VPWR VPWR _4503_/S sky130_fd_sc_hd__buf_2
XFILLER_35_149 VGND VGND VPWR VPWR sky130_fd_sc_hd__decap_3
XFILLER_90_233 VGND VGND VPWR VPWR sky130_fd_sc_hd__decap_3
Xplace414 _4419_/B1 VGND VGND VPWR VPWR _4346_/B1 sky130_fd_sc_hd__buf_2
Xplace425 _3973_/S VGND VGND VPWR VPWR _3996_/S sky130_fd_sc_hd__buf_2
Xplace436 _5156_/S VGND VGND VPWR VPWR _4836_/S sky130_fd_sc_hd__buf_2
Xplace447 _3318_/B VGND VGND VPWR VPWR _4433_/B sky130_fd_sc_hd__buf_2
XPHY_EDGE_ROW_82_Left_199 VGND VGND VPWR VPWR sky130_fd_sc_hd__decap_3
XFILLER_44_672 VGND VGND VPWR VPWR sky130_fd_sc_hd__decap_3
Xplace458 _6980_/Q VGND VGND VPWR VPWR _3353_/A sky130_fd_sc_hd__buf_2
XFILLER_16_396 VGND VGND VPWR VPWR sky130_fd_sc_hd__decap_3
XFILLER_31_322 VGND VGND VPWR VPWR sky130_fd_sc_hd__fill_1
XFILLER_91_6 VGND VGND VPWR VPWR sky130_fd_sc_hd__decap_3
XFILLER_31_388 VGND VGND VPWR VPWR sky130_fd_sc_hd__fill_1
XFILLER_31_399 VGND VGND VPWR VPWR sky130_fd_sc_hd__decap_3
XFILLER_61_90 VGND VGND VPWR VPWR sky130_fd_sc_hd__decap_3
XANTENNA_1 _5117_/B VGND VGND VPWR VPWR sky130_fd_sc_hd__diode_2
XFILLER_6_41 VGND VGND VPWR VPWR sky130_fd_sc_hd__decap_3
XFILLER_8_584 VGND VGND VPWR VPWR sky130_fd_sc_hd__decap_3
X_4431_ _7271_/Q _4437_/A2 _4428_/X _4430_/X VGND VGND VPWR VPWR _4431_/X sky130_fd_sc_hd__a211o_2
XFILLER_6_74 VGND VGND VPWR VPWR sky130_fd_sc_hd__decap_3
XFILLER_6_85 VGND VGND VPWR VPWR sky130_fd_sc_hd__decap_3
XFILLER_113_600 VGND VGND VPWR VPWR sky130_fd_sc_hd__decap_3
X_7150_ _7372_/CLK _7150_/D _6430_/Y VGND VGND VPWR VPWR _7150_/Q sky130_fd_sc_hd__dfrtp_2
X_4362_ _4362_/A _4362_/B _4362_/C VGND VGND VPWR VPWR _4362_/X sky130_fd_sc_hd__and3_2
XFILLER_98_300 VGND VGND VPWR VPWR sky130_fd_sc_hd__decap_3
XFILLER_112_121 VGND VGND VPWR VPWR sky130_fd_sc_hd__decap_3
XFILLER_113_644 VGND VGND VPWR VPWR sky130_fd_sc_hd__decap_3
X_7081_ _7266_/CLK _7081_/D _6361_/Y VGND VGND VPWR VPWR _7081_/Q sky130_fd_sc_hd__dfrtp_2
X_4293_ _4294_/A _4612_/B VGND VGND VPWR VPWR _4293_/X sky130_fd_sc_hd__and2b_2
X_3313_ _5670_/A _3353_/A _3371_/A _5129_/A VGND VGND VPWR VPWR _4467_/B sky130_fd_sc_hd__nand4b_4
XFILLER_98_333 VGND VGND VPWR VPWR sky130_fd_sc_hd__decap_3
XFILLER_112_165 VGND VGND VPWR VPWR sky130_fd_sc_hd__decap_3
XFILLER_86_528 VGND VGND VPWR VPWR sky130_fd_sc_hd__decap_3
XFILLER_86_539 VGND VGND VPWR VPWR sky130_fd_sc_hd__decap_3
XFILLER_98_377 VGND VGND VPWR VPWR sky130_fd_sc_hd__decap_3
XFILLER_100_327 VGND VGND VPWR VPWR sky130_fd_sc_hd__decap_3
XFILLER_39_444 VGND VGND VPWR VPWR sky130_fd_sc_hd__decap_3
XFILLER_94_572 VGND VGND VPWR VPWR sky130_fd_sc_hd__decap_3
XFILLER_54_414 VGND VGND VPWR VPWR sky130_fd_sc_hd__decap_3
XFILLER_66_274 VGND VGND VPWR VPWR sky130_fd_sc_hd__decap_3
XFILLER_19_190 VGND VGND VPWR VPWR sky130_fd_sc_hd__decap_3
X_6934_ _7005_/CLK _6934_/D VGND VGND VPWR VPWR _6934_/Q sky130_fd_sc_hd__dfxtp_2
XTAP_TAPCELL_ROW_1_259 VGND VPWR sky130_fd_sc_hd__tapvpwrvgnd_1
XFILLER_41_108 VGND VGND VPWR VPWR sky130_fd_sc_hd__decap_3
XFILLER_81_277 VGND VGND VPWR VPWR sky130_fd_sc_hd__decap_3
XFILLER_22_322 VGND VGND VPWR VPWR sky130_fd_sc_hd__decap_3
XFILLER_34_171 VGND VGND VPWR VPWR sky130_fd_sc_hd__decap_3
XFILLER_50_642 VGND VGND VPWR VPWR sky130_fd_sc_hd__fill_2
X_6865_ _6931_/CLK _6865_/D VGND VGND VPWR VPWR _6865_/Q sky130_fd_sc_hd__dfxtp_2
XFILLER_50_675 VGND VGND VPWR VPWR sky130_fd_sc_hd__decap_3
X_6796_ _7392_/CLK _6796_/D VGND VGND VPWR VPWR _6796_/Q sky130_fd_sc_hd__dfxtp_2
XFILLER_41_38 VGND VGND VPWR VPWR sky130_fd_sc_hd__decap_3
XFILLER_108_449 VGND VGND VPWR VPWR sky130_fd_sc_hd__fill_2
X_5678_ _7345_/Q hold917/X _5721_/S VGND VGND VPWR VPWR _5678_/X sky130_fd_sc_hd__mux2_2
X_4629_ _4629_/A _4629_/B VGND VGND VPWR VPWR _4629_/Y sky130_fd_sc_hd__nor2_2
X_7348_ clkload5/A _7348_/D _6628_/Y VGND VGND VPWR VPWR _7348_/Q sky130_fd_sc_hd__dfrtp_2
XFILLER_103_110 VGND VGND VPWR VPWR sky130_fd_sc_hd__fill_2
XFILLER_103_132 VGND VGND VPWR VPWR sky130_fd_sc_hd__decap_3
XFILLER_104_666 VGND VGND VPWR VPWR sky130_fd_sc_hd__decap_3
XFILLER_89_333 VGND VGND VPWR VPWR sky130_fd_sc_hd__decap_3
X_7279_ _7279_/CLK _7279_/D _6559_/Y VGND VGND VPWR VPWR _7279_/Q sky130_fd_sc_hd__dfrtp_2
Xhold584 _6932_/Q VGND VGND VPWR VPWR _6932_/D sky130_fd_sc_hd__dlygate4sd3_1
Xhold595 _6854_/Q VGND VGND VPWR VPWR _6854_/D sky130_fd_sc_hd__dlygate4sd3_1
XTAP_TAPCELL_ROW_9_359 VGND VPWR sky130_fd_sc_hd__tapvpwrvgnd_1
XFILLER_106_53 VGND VGND VPWR VPWR sky130_fd_sc_hd__decap_3
XFILLER_77_517 VGND VGND VPWR VPWR sky130_fd_sc_hd__decap_3
XFILLER_89_388 VGND VGND VPWR VPWR sky130_fd_sc_hd__decap_3
XFILLER_89_399 VGND VGND VPWR VPWR sky130_fd_sc_hd__decap_3
XFILLER_103_187 VGND VGND VPWR VPWR sky130_fd_sc_hd__decap_3
XFILLER_66_24 VGND VGND VPWR VPWR sky130_fd_sc_hd__decap_3
XFILLER_18_606 VGND VGND VPWR VPWR sky130_fd_sc_hd__decap_3
XFILLER_45_403 VGND VGND VPWR VPWR sky130_fd_sc_hd__decap_3
XFILLER_85_561 VGND VGND VPWR VPWR sky130_fd_sc_hd__decap_3
XFILLER_57_296 VGND VGND VPWR VPWR sky130_fd_sc_hd__decap_3
XFILLER_85_594 VGND VGND VPWR VPWR sky130_fd_sc_hd__decap_3
XTAP_TAPCELL_ROW_56_921 VGND VPWR sky130_fd_sc_hd__tapvpwrvgnd_1
XFILLER_17_138 VGND VGND VPWR VPWR sky130_fd_sc_hd__decap_3
XFILLER_45_447 VGND VGND VPWR VPWR sky130_fd_sc_hd__fill_1
XFILLER_72_244 VGND VGND VPWR VPWR sky130_fd_sc_hd__decap_3
XFILLER_82_12 VGND VGND VPWR VPWR sky130_fd_sc_hd__fill_2
XFILLER_82_56 VGND VGND VPWR VPWR sky130_fd_sc_hd__decap_3
XFILLER_13_322 VGND VGND VPWR VPWR sky130_fd_sc_hd__fill_2
XFILLER_13_333 VGND VGND VPWR VPWR sky130_fd_sc_hd__decap_3
XFILLER_40_141 VGND VGND VPWR VPWR sky130_fd_sc_hd__decap_3
XFILLER_41_653 VGND VGND VPWR VPWR sky130_fd_sc_hd__decap_3
XFILLER_40_174 VGND VGND VPWR VPWR sky130_fd_sc_hd__decap_3
XTAP_TAPCELL_ROW_97_1411 VGND VPWR sky130_fd_sc_hd__tapvpwrvgnd_1
XFILLER_31_60 VGND VGND VPWR VPWR sky130_fd_sc_hd__decap_3
XFILLER_56_9 VGND VGND VPWR VPWR sky130_fd_sc_hd__decap_3
XFILLER_107_460 VGND VGND VPWR VPWR sky130_fd_sc_hd__fill_1
XFILLER_114_419 VGND VGND VPWR VPWR sky130_fd_sc_hd__fill_1
XFILLER_99_119 VGND VGND VPWR VPWR sky130_fd_sc_hd__fill_1
XFILLER_110_625 VGND VGND VPWR VPWR sky130_fd_sc_hd__decap_3
XFILLER_68_539 VGND VGND VPWR VPWR sky130_fd_sc_hd__fill_2
XFILLER_110_669 VGND VGND VPWR VPWR sky130_fd_sc_hd__decap_3
XFILLER_95_369 VGND VGND VPWR VPWR sky130_fd_sc_hd__decap_3
XFILLER_48_274 VGND VGND VPWR VPWR sky130_fd_sc_hd__fill_1
XFILLER_76_572 VGND VGND VPWR VPWR sky130_fd_sc_hd__decap_3
XFILLER_91_520 VGND VGND VPWR VPWR sky130_fd_sc_hd__decap_3
XPHY_EDGE_ROW_90_Left_207 VGND VGND VPWR VPWR sky130_fd_sc_hd__decap_3
XFILLER_36_447 VGND VGND VPWR VPWR sky130_fd_sc_hd__decap_3
XFILLER_36_458 VGND VGND VPWR VPWR sky130_fd_sc_hd__decap_3
XFILLER_91_564 VGND VGND VPWR VPWR sky130_fd_sc_hd__decap_3
XFILLER_51_417 VGND VGND VPWR VPWR sky130_fd_sc_hd__decap_3
XFILLER_16_171 VGND VGND VPWR VPWR sky130_fd_sc_hd__fill_1
XFILLER_32_642 VGND VGND VPWR VPWR sky130_fd_sc_hd__fill_2
Xplace288 _3893_/B1 VGND VGND VPWR VPWR _3878_/A2 sky130_fd_sc_hd__buf_2
Xplace277 _3912_/A2 VGND VGND VPWR VPWR _3926_/A2 sky130_fd_sc_hd__buf_2
Xplace266 _3891_/B1 VGND VGND VPWR VPWR _3878_/B1 sky130_fd_sc_hd__buf_2
X_3931_ _7374_/Q _4474_/A0 _3947_/S VGND VGND VPWR VPWR _7374_/D sky130_fd_sc_hd__mux2_2
XTAP_TAPCELL_ROW_34_659 VGND VPWR sky130_fd_sc_hd__tapvpwrvgnd_1
XFILLER_31_152 VGND VGND VPWR VPWR sky130_fd_sc_hd__decap_3
XFILLER_32_675 VGND VGND VPWR VPWR sky130_fd_sc_hd__decap_3
Xplace299 _3640_/X VGND VGND VPWR VPWR _3665_/B sky130_fd_sc_hd__buf_2
X_6650_ _6683_/A VGND VGND VPWR VPWR _6650_/Y sky130_fd_sc_hd__inv_2
X_3862_ _6923_/Q _3926_/A2 _3862_/B1 _6787_/Q VGND VGND VPWR VPWR _3862_/X sky130_fd_sc_hd__a22o_2
X_6581_ _6642_/A VGND VGND VPWR VPWR _6581_/Y sky130_fd_sc_hd__inv_2
XFILLER_31_196 VGND VGND VPWR VPWR sky130_fd_sc_hd__decap_3
X_3793_ _6756_/Q _3878_/A2 _3878_/B1 _6768_/Q VGND VGND VPWR VPWR _3793_/X sky130_fd_sc_hd__a22o_2
XFILLER_105_408 VGND VGND VPWR VPWR sky130_fd_sc_hd__decap_3
X_7202_ _7267_/CLK _7202_/D _6482_/Y VGND VGND VPWR VPWR _7202_/Q sky130_fd_sc_hd__dfrtp_2
X_5394_ _5394_/A0 _4964_/X _5417_/S VGND VGND VPWR VPWR _7136_/D sky130_fd_sc_hd__mux2_2
X_4414_ _7240_/Q _4433_/B _3949_/S _7208_/Q VGND VGND VPWR VPWR _4414_/X sky130_fd_sc_hd__a22o_2
X_7133_ _7397_/CLK _7133_/D _6413_/Y VGND VGND VPWR VPWR _7133_/Q sky130_fd_sc_hd__dfrtp_2
X_4345_ _4343_/X _4345_/B VGND VGND VPWR VPWR _5101_/B sky130_fd_sc_hd__nand2b_2
XFILLER_99_631 VGND VGND VPWR VPWR sky130_fd_sc_hd__decap_3
XFILLER_101_603 VGND VGND VPWR VPWR sky130_fd_sc_hd__decap_3
XTAP_TAPCELL_ROW_6_329 VGND VPWR sky130_fd_sc_hd__tapvpwrvgnd_1
XTAP_TAPCELL_ROW_6_318 VGND VPWR sky130_fd_sc_hd__tapvpwrvgnd_1
XFILLER_100_124 VGND VGND VPWR VPWR sky130_fd_sc_hd__decap_3
X_7064_ clkload9/A _7064_/D _6344_/Y VGND VGND VPWR VPWR _7064_/Q sky130_fd_sc_hd__dfrtp_2
XFILLER_100_168 VGND VGND VPWR VPWR sky130_fd_sc_hd__decap_3
XFILLER_101_669 VGND VGND VPWR VPWR sky130_fd_sc_hd__decap_3
XFILLER_39_252 VGND VGND VPWR VPWR sky130_fd_sc_hd__decap_3
XFILLER_67_561 VGND VGND VPWR VPWR sky130_fd_sc_hd__decap_3
XFILLER_27_414 VGND VGND VPWR VPWR sky130_fd_sc_hd__decap_3
XFILLER_36_27 VGND VGND VPWR VPWR sky130_fd_sc_hd__fill_1
XFILLER_67_583 VGND VGND VPWR VPWR sky130_fd_sc_hd__decap_3
XFILLER_27_458 VGND VGND VPWR VPWR sky130_fd_sc_hd__decap_3
XFILLER_36_49 VGND VGND VPWR VPWR sky130_fd_sc_hd__decap_3
XFILLER_39_296 VGND VGND VPWR VPWR sky130_fd_sc_hd__fill_2
XFILLER_82_542 VGND VGND VPWR VPWR sky130_fd_sc_hd__fill_2
XFILLER_94_391 VGND VGND VPWR VPWR sky130_fd_sc_hd__decap_3
XFILLER_54_277 VGND VGND VPWR VPWR sky130_fd_sc_hd__decap_3
XFILLER_82_586 VGND VGND VPWR VPWR sky130_fd_sc_hd__fill_2
XFILLER_82_597 VGND VGND VPWR VPWR sky130_fd_sc_hd__decap_3
XTAP_TAPCELL_ROW_68_1067 VGND VPWR sky130_fd_sc_hd__tapvpwrvgnd_1
XFILLER_23_620 VGND VGND VPWR VPWR sky130_fd_sc_hd__fill_2
X_6917_ _6977_/CLK _6917_/D VGND VGND VPWR VPWR _6917_/Q sky130_fd_sc_hd__dfxtp_2
XTAP_TAPCELL_ROW_81_1223 VGND VPWR sky130_fd_sc_hd__tapvpwrvgnd_1
XFILLER_22_130 VGND VGND VPWR VPWR sky130_fd_sc_hd__decap_3
XFILLER_22_141 VGND VGND VPWR VPWR sky130_fd_sc_hd__decap_3
X_6848_ _6978_/CLK _6848_/D VGND VGND VPWR VPWR _6848_/Q sky130_fd_sc_hd__dfxtp_2
XFILLER_10_303 VGND VGND VPWR VPWR sky130_fd_sc_hd__decap_3
X_6779_ _7387_/CLK _6779_/D VGND VGND VPWR VPWR _6779_/Q sky130_fd_sc_hd__dfxtp_2
XTAP_TAPCELL_ROW_79_1196 VGND VPWR sky130_fd_sc_hd__tapvpwrvgnd_1
XFILLER_77_12 VGND VGND VPWR VPWR sky130_fd_sc_hd__decap_3
XTAP_TAPCELL_ROW_92_1352 VGND VPWR sky130_fd_sc_hd__tapvpwrvgnd_1
XFILLER_104_474 VGND VGND VPWR VPWR sky130_fd_sc_hd__fill_2
XFILLER_77_303 VGND VGND VPWR VPWR sky130_fd_sc_hd__decap_3
XFILLER_77_45 VGND VGND VPWR VPWR sky130_fd_sc_hd__decap_3
XFILLER_104_485 VGND VGND VPWR VPWR sky130_fd_sc_hd__decap_3
XFILLER_77_89 VGND VGND VPWR VPWR sky130_fd_sc_hd__decap_3
XFILLER_93_33 VGND VGND VPWR VPWR sky130_fd_sc_hd__decap_3
XFILLER_73_542 VGND VGND VPWR VPWR sky130_fd_sc_hd__decap_3
XFILLER_93_66 VGND VGND VPWR VPWR sky130_fd_sc_hd__fill_2
Xhold1070 _7331_/Q VGND VGND VPWR VPWR _4497_/A0 sky130_fd_sc_hd__dlygate4sd3_1
Xhold1081 _7219_/Q VGND VGND VPWR VPWR _5219_/A sky130_fd_sc_hd__dlygate4sd3_1
Xhold1092 _7215_/Q VGND VGND VPWR VPWR _5227_/A1 sky130_fd_sc_hd__dlygate4sd3_1
XFILLER_33_417 VGND VGND VPWR VPWR sky130_fd_sc_hd__decap_3
XFILLER_45_255 VGND VGND VPWR VPWR sky130_fd_sc_hd__decap_3
XFILLER_45_277 VGND VGND VPWR VPWR sky130_fd_sc_hd__decap_3
XFILLER_60_247 VGND VGND VPWR VPWR sky130_fd_sc_hd__decap_3
XFILLER_14_642 VGND VGND VPWR VPWR sky130_fd_sc_hd__fill_2
XTAP_TAPCELL_ROW_31_629 VGND VPWR sky130_fd_sc_hd__tapvpwrvgnd_1
XTAP_TAPCELL_ROW_31_618 VGND VPWR sky130_fd_sc_hd__tapvpwrvgnd_1
XFILLER_9_101 VGND VGND VPWR VPWR sky130_fd_sc_hd__decap_3
XFILLER_13_196 VGND VGND VPWR VPWR sky130_fd_sc_hd__decap_3
XFILLER_9_145 VGND VGND VPWR VPWR sky130_fd_sc_hd__fill_2
XFILLER_5_340 VGND VGND VPWR VPWR sky130_fd_sc_hd__fill_1
XTAP_TAPCELL_ROW_11_386 VGND VPWR sky130_fd_sc_hd__tapvpwrvgnd_1
XFILLER_114_227 VGND VGND VPWR VPWR sky130_fd_sc_hd__decap_3
XFILLER_54_6 VGND VGND VPWR VPWR sky130_fd_sc_hd__decap_3
XFILLER_96_601 VGND VGND VPWR VPWR sky130_fd_sc_hd__decap_3
X_4130_ _7235_/Q _4430_/A2 _4430_/B1 _7171_/Q _4129_/X VGND VGND VPWR VPWR _4130_/X
+ sky130_fd_sc_hd__a221o_2
XFILLER_3_42 VGND VGND VPWR VPWR sky130_fd_sc_hd__decap_3
XFILLER_68_325 VGND VGND VPWR VPWR sky130_fd_sc_hd__decap_3
XFILLER_95_111 VGND VGND VPWR VPWR sky130_fd_sc_hd__fill_1
XFILLER_96_656 VGND VGND VPWR VPWR sky130_fd_sc_hd__decap_3
XFILLER_3_75 VGND VGND VPWR VPWR sky130_fd_sc_hd__decap_3
XFILLER_49_561 VGND VGND VPWR VPWR sky130_fd_sc_hd__fill_2
XFILLER_68_358 VGND VGND VPWR VPWR sky130_fd_sc_hd__decap_3
XFILLER_95_144 VGND VGND VPWR VPWR sky130_fd_sc_hd__decap_3
XFILLER_95_166 VGND VGND VPWR VPWR sky130_fd_sc_hd__fill_2
XFILLER_96_689 VGND VGND VPWR VPWR sky130_fd_sc_hd__decap_3
X_4061_ _7244_/Q _4433_/B _4436_/B1 _7180_/Q VGND VGND VPWR VPWR _4061_/X sky130_fd_sc_hd__a22o_2
XFILLER_36_200 VGND VGND VPWR VPWR sky130_fd_sc_hd__decap_3
XFILLER_95_199 VGND VGND VPWR VPWR sky130_fd_sc_hd__decap_3
XTAP_TAPCELL_ROW_39_718 VGND VPWR sky130_fd_sc_hd__tapvpwrvgnd_1
XFILLER_64_575 VGND VGND VPWR VPWR sky130_fd_sc_hd__decap_3
XFILLER_91_361 VGND VGND VPWR VPWR sky130_fd_sc_hd__decap_3
XFILLER_24_439 VGND VGND VPWR VPWR sky130_fd_sc_hd__decap_3
XFILLER_51_225 VGND VGND VPWR VPWR sky130_fd_sc_hd__decap_3
X_4963_ _4963_/A _4963_/B VGND VGND VPWR VPWR _6994_/D sky130_fd_sc_hd__nor2_2
XTAP_TAPCELL_ROW_19_475 VGND VPWR sky130_fd_sc_hd__tapvpwrvgnd_1
X_6702_ _7392_/CLK _6702_/D VGND VGND VPWR VPWR _6702_/Q sky130_fd_sc_hd__dfxtp_2
X_3914_ _3923_/A1 _3911_/X _3913_/X _3714_/X VGND VGND VPWR VPWR _3914_/X sky130_fd_sc_hd__a22o_2
XFILLER_20_634 VGND VGND VPWR VPWR sky130_fd_sc_hd__fill_1
X_6633_ _6640_/A VGND VGND VPWR VPWR _6633_/Y sky130_fd_sc_hd__inv_2
X_4894_ _4908_/A _4908_/B VGND VGND VPWR VPWR _4909_/B sky130_fd_sc_hd__and2_2
XFILLER_20_645 VGND VGND VPWR VPWR sky130_fd_sc_hd__decap_3
XFILLER_22_18 VGND VGND VPWR VPWR sky130_fd_sc_hd__decap_3
X_3845_ _3845_/A _3845_/B VGND VGND VPWR VPWR _3845_/X sky130_fd_sc_hd__or2_2
X_6564_ _6599_/A VGND VGND VPWR VPWR _6564_/Y sky130_fd_sc_hd__inv_2
X_3776_ _6727_/Q _3906_/A2 _3886_/B1 _6977_/Q VGND VGND VPWR VPWR _3776_/X sky130_fd_sc_hd__a22o_2
X_6495_ _6608_/A VGND VGND VPWR VPWR _6495_/Y sky130_fd_sc_hd__inv_2
XFILLER_105_216 VGND VGND VPWR VPWR sky130_fd_sc_hd__decap_3
XTAP_TAPCELL_ROW_115_1628 VGND VPWR sky130_fd_sc_hd__tapvpwrvgnd_1
Xoutput486 _3640_/X VGND VGND VPWR VPWR alu_result_out[3] sky130_fd_sc_hd__clkdlybuf4s25_1
Xoutput475 _5663_/C VGND VGND VPWR VPWR alu_result_out[22] sky130_fd_sc_hd__clkdlybuf4s25_1
Xoutput464 _5658_/B VGND VGND VPWR VPWR alu_result_out[12] sky130_fd_sc_hd__clkdlybuf4s25_1
X_5377_ _5377_/A0 _4822_/X _5383_/S VGND VGND VPWR VPWR _7144_/D sky130_fd_sc_hd__mux2_2
XFILLER_101_411 VGND VGND VPWR VPWR sky130_fd_sc_hd__decap_3
XFILLER_59_314 VGND VGND VPWR VPWR sky130_fd_sc_hd__decap_3
XFILLER_87_623 VGND VGND VPWR VPWR sky130_fd_sc_hd__decap_3
X_7116_ _7374_/CLK _7116_/D _6396_/Y VGND VGND VPWR VPWR _7116_/Q sky130_fd_sc_hd__dfrtp_2
Xoutput497 _3525_/B VGND VGND VPWR VPWR instruction_out[14] sky130_fd_sc_hd__clkdlybuf4s25_1
X_4328_ _4362_/A _4362_/B _4362_/C VGND VGND VPWR VPWR _5057_/B sky130_fd_sc_hd__a21boi_2
XFILLER_99_483 VGND VGND VPWR VPWR sky130_fd_sc_hd__decap_3
XFILLER_101_444 VGND VGND VPWR VPWR sky130_fd_sc_hd__decap_3
XFILLER_113_293 VGND VGND VPWR VPWR sky130_fd_sc_hd__decap_3
XFILLER_59_369 VGND VGND VPWR VPWR sky130_fd_sc_hd__decap_3
XFILLER_74_306 VGND VGND VPWR VPWR sky130_fd_sc_hd__fill_2
XFILLER_86_144 VGND VGND VPWR VPWR sky130_fd_sc_hd__decap_3
X_7047_ _7401_/CLK _7047_/D _6327_/Y VGND VGND VPWR VPWR _7047_/Q sky130_fd_sc_hd__dfrtp_2
XFILLER_103_21 VGND VGND VPWR VPWR sky130_fd_sc_hd__decap_3
XFILLER_67_391 VGND VGND VPWR VPWR sky130_fd_sc_hd__fill_1
XFILLER_103_54 VGND VGND VPWR VPWR sky130_fd_sc_hd__fill_2
XFILLER_27_266 VGND VGND VPWR VPWR sky130_fd_sc_hd__decap_3
XFILLER_55_564 VGND VGND VPWR VPWR sky130_fd_sc_hd__decap_3
XFILLER_103_87 VGND VGND VPWR VPWR sky130_fd_sc_hd__decap_3
XFILLER_42_236 VGND VGND VPWR VPWR sky130_fd_sc_hd__decap_3
XFILLER_55_597 VGND VGND VPWR VPWR sky130_fd_sc_hd__decap_3
XFILLER_63_47 VGND VGND VPWR VPWR sky130_fd_sc_hd__decap_3
XFILLER_82_383 VGND VGND VPWR VPWR sky130_fd_sc_hd__decap_3
XFILLER_50_280 VGND VGND VPWR VPWR sky130_fd_sc_hd__decap_3
XFILLER_6_115 VGND VGND VPWR VPWR sky130_fd_sc_hd__decap_3
XFILLER_12_62 VGND VGND VPWR VPWR sky130_fd_sc_hd__fill_1
XFILLER_6_159 VGND VGND VPWR VPWR sky130_fd_sc_hd__fill_2
XFILLER_2_321 VGND VGND VPWR VPWR sky130_fd_sc_hd__decap_3
XFILLER_2_365 VGND VGND VPWR VPWR sky130_fd_sc_hd__decap_3
XFILLER_88_88 VGND VGND VPWR VPWR sky130_fd_sc_hd__decap_3
XFILLER_2_398 VGND VGND VPWR VPWR sky130_fd_sc_hd__decap_3
XFILLER_78_645 VGND VGND VPWR VPWR sky130_fd_sc_hd__decap_3
XFILLER_104_293 VGND VGND VPWR VPWR sky130_fd_sc_hd__decap_3
XFILLER_78_667 VGND VGND VPWR VPWR sky130_fd_sc_hd__decap_3
XFILLER_65_317 VGND VGND VPWR VPWR sky130_fd_sc_hd__decap_3
XFILLER_92_114 VGND VGND VPWR VPWR sky130_fd_sc_hd__decap_3
XFILLER_18_233 VGND VGND VPWR VPWR sky130_fd_sc_hd__decap_3
XFILLER_77_199 VGND VGND VPWR VPWR sky130_fd_sc_hd__decap_3
XFILLER_92_147 VGND VGND VPWR VPWR sky130_fd_sc_hd__fill_2
XFILLER_93_659 VGND VGND VPWR VPWR sky130_fd_sc_hd__decap_3
XFILLER_18_266 VGND VGND VPWR VPWR sky130_fd_sc_hd__decap_3
XFILLER_37_81 VGND VGND VPWR VPWR sky130_fd_sc_hd__decap_3
XFILLER_46_564 VGND VGND VPWR VPWR sky130_fd_sc_hd__decap_3
XFILLER_46_575 VGND VGND VPWR VPWR sky130_fd_sc_hd__decap_3
XFILLER_73_350 VGND VGND VPWR VPWR sky130_fd_sc_hd__fill_1
XFILLER_80_309 VGND VGND VPWR VPWR sky130_fd_sc_hd__decap_3
XFILLER_18_299 VGND VGND VPWR VPWR sky130_fd_sc_hd__decap_3
XFILLER_33_214 VGND VGND VPWR VPWR sky130_fd_sc_hd__decap_3
XFILLER_33_225 VGND VGND VPWR VPWR sky130_fd_sc_hd__decap_3
XFILLER_46_597 VGND VGND VPWR VPWR sky130_fd_sc_hd__decap_3
XFILLER_61_545 VGND VGND VPWR VPWR sky130_fd_sc_hd__decap_3
XFILLER_14_450 VGND VGND VPWR VPWR sky130_fd_sc_hd__decap_3
XFILLER_33_247 VGND VGND VPWR VPWR sky130_fd_sc_hd__decap_3
XFILLER_33_269 VGND VGND VPWR VPWR sky130_fd_sc_hd__decap_3
XFILLER_61_567 VGND VGND VPWR VPWR sky130_fd_sc_hd__decap_3
XTAP_TAPCELL_ROW_16_445 VGND VPWR sky130_fd_sc_hd__tapvpwrvgnd_1
XTAP_TAPCELL_ROW_44_776 VGND VPWR sky130_fd_sc_hd__tapvpwrvgnd_1
X_3630_ _3630_/A _3630_/B VGND VGND VPWR VPWR _3636_/B sky130_fd_sc_hd__and2_2
X_3561_ _6982_/Q _5670_/A _5668_/A VGND VGND VPWR VPWR _3561_/X sky130_fd_sc_hd__or3_2
XFILLER_52_3 VGND VGND VPWR VPWR sky130_fd_sc_hd__decap_3
XFILLER_6_660 VGND VGND VPWR VPWR sky130_fd_sc_hd__decap_3
X_5300_ _5300_/A0 _4752_/X _5323_/S VGND VGND VPWR VPWR _7180_/D sky130_fd_sc_hd__mux2_2
XFILLER_115_536 VGND VGND VPWR VPWR sky130_fd_sc_hd__decap_3
XFILLER_5_181 VGND VGND VPWR VPWR sky130_fd_sc_hd__decap_3
X_6280_ _6280_/A VGND VGND VPWR VPWR _6280_/Y sky130_fd_sc_hd__inv_2
X_3492_ _7055_/Q _4305_/B _3487_/X _3491_/X VGND VGND VPWR VPWR _4460_/B sky130_fd_sc_hd__o22a_2
XFILLER_69_612 VGND VGND VPWR VPWR sky130_fd_sc_hd__decap_3
XFILLER_88_409 VGND VGND VPWR VPWR sky130_fd_sc_hd__fill_2
XFILLER_68_133 VGND VGND VPWR VPWR sky130_fd_sc_hd__decap_3
XFILLER_68_144 VGND VGND VPWR VPWR sky130_fd_sc_hd__decap_3
X_5093_ _5581_/S _3867_/X _5658_/C _5092_/X _3346_/A VGND VGND VPWR VPWR _5093_/X
+ sky130_fd_sc_hd__o32a_2
X_4113_ _7364_/Q _4196_/A2 _4112_/X _4419_/C1 VGND VGND VPWR VPWR _4113_/X sky130_fd_sc_hd__a211o_2
XTAP_TAPCELL_ROW_110_1569 VGND VPWR sky130_fd_sc_hd__tapvpwrvgnd_1
XFILLER_68_177 VGND VGND VPWR VPWR sky130_fd_sc_hd__decap_3
XFILLER_96_475 VGND VGND VPWR VPWR sky130_fd_sc_hd__fill_1
XFILLER_96_486 VGND VGND VPWR VPWR sky130_fd_sc_hd__decap_3
XFILLER_17_18 VGND VGND VPWR VPWR sky130_fd_sc_hd__decap_3
XFILLER_83_125 VGND VGND VPWR VPWR sky130_fd_sc_hd__decap_3
X_4044_ _7277_/Q _4437_/A2 _4041_/X _4043_/X VGND VGND VPWR VPWR _4044_/X sky130_fd_sc_hd__a211o_2
XFILLER_37_564 VGND VGND VPWR VPWR sky130_fd_sc_hd__decap_3
XFILLER_52_501 VGND VGND VPWR VPWR sky130_fd_sc_hd__decap_3
XFILLER_83_158 VGND VGND VPWR VPWR sky130_fd_sc_hd__decap_3
XFILLER_83_169 VGND VGND VPWR VPWR sky130_fd_sc_hd__decap_3
XFILLER_91_180 VGND VGND VPWR VPWR sky130_fd_sc_hd__fill_2
XFILLER_92_681 VGND VGND VPWR VPWR sky130_fd_sc_hd__decap_3
XTAP_TAPCELL_ROW_65_1037 VGND VPWR sky130_fd_sc_hd__tapvpwrvgnd_1
XTAP_TAPCELL_ROW_65_1026 VGND VPWR sky130_fd_sc_hd__tapvpwrvgnd_1
XFILLER_52_589 VGND VGND VPWR VPWR sky130_fd_sc_hd__decap_3
X_4946_ _4946_/A0 _4945_/X _5028_/S VGND VGND VPWR VPWR _7265_/D sky130_fd_sc_hd__mux2_2
XFILLER_32_280 VGND VGND VPWR VPWR sky130_fd_sc_hd__fill_2
X_4877_ _4799_/A _5663_/C _3753_/X _3346_/A VGND VGND VPWR VPWR _4877_/X sky130_fd_sc_hd__o211a_2
X_6616_ _6616_/A VGND VGND VPWR VPWR _6616_/Y sky130_fd_sc_hd__inv_2
X_3828_ _6926_/Q _3912_/A2 _3913_/A2 _6790_/Q _3827_/X VGND VGND VPWR VPWR _3828_/X
+ sky130_fd_sc_hd__a221o_2
X_6547_ _6547_/A VGND VGND VPWR VPWR _6547_/Y sky130_fd_sc_hd__inv_2
XFILLER_106_514 VGND VGND VPWR VPWR sky130_fd_sc_hd__fill_2
X_3759_ _6797_/Q _3759_/A2 _3826_/B1 _6885_/Q VGND VGND VPWR VPWR _3759_/X sky130_fd_sc_hd__a22o_2
X_6478_ _6644_/A VGND VGND VPWR VPWR _6478_/Y sky130_fd_sc_hd__inv_2
XTAP_TAPCELL_ROW_76_1166 VGND VPWR sky130_fd_sc_hd__tapvpwrvgnd_1
X_5429_ _5429_/A0 _4470_/X _5429_/S VGND VGND VPWR VPWR _7119_/D sky130_fd_sc_hd__mux2_2
XFILLER_58_25 VGND VGND VPWR VPWR sky130_fd_sc_hd__decap_3
XFILLER_58_47 VGND VGND VPWR VPWR sky130_fd_sc_hd__decap_3
XFILLER_58_69 VGND VGND VPWR VPWR sky130_fd_sc_hd__decap_3
XFILLER_59_144 VGND VGND VPWR VPWR sky130_fd_sc_hd__fill_2
XFILLER_75_604 VGND VGND VPWR VPWR sky130_fd_sc_hd__decap_3
XFILLER_87_442 VGND VGND VPWR VPWR sky130_fd_sc_hd__decap_3
XFILLER_74_114 VGND VGND VPWR VPWR sky130_fd_sc_hd__decap_3
XFILLER_75_626 VGND VGND VPWR VPWR sky130_fd_sc_hd__decap_3
XFILLER_75_637 VGND VGND VPWR VPWR sky130_fd_sc_hd__fill_1
XFILLER_101_296 VGND VGND VPWR VPWR sky130_fd_sc_hd__decap_3
XFILLER_114_53 VGND VGND VPWR VPWR sky130_fd_sc_hd__decap_3
XFILLER_59_199 VGND VGND VPWR VPWR sky130_fd_sc_hd__decap_3
XFILLER_75_659 VGND VGND VPWR VPWR sky130_fd_sc_hd__decap_3
XFILLER_114_97 VGND VGND VPWR VPWR sky130_fd_sc_hd__decap_3
XFILLER_74_158 VGND VGND VPWR VPWR sky130_fd_sc_hd__decap_3
XFILLER_74_35 VGND VGND VPWR VPWR sky130_fd_sc_hd__decap_3
XFILLER_90_618 VGND VGND VPWR VPWR sky130_fd_sc_hd__decap_3
XFILLER_15_214 VGND VGND VPWR VPWR sky130_fd_sc_hd__decap_3
XFILLER_15_225 VGND VGND VPWR VPWR sky130_fd_sc_hd__decap_3
XFILLER_28_597 VGND VGND VPWR VPWR sky130_fd_sc_hd__decap_3
XFILLER_74_79 VGND VGND VPWR VPWR sky130_fd_sc_hd__decap_3
XFILLER_82_180 VGND VGND VPWR VPWR sky130_fd_sc_hd__decap_3
XTAP_TAPCELL_ROW_87_1295 VGND VPWR sky130_fd_sc_hd__tapvpwrvgnd_1
XFILLER_15_258 VGND VGND VPWR VPWR sky130_fd_sc_hd__decap_3
XFILLER_43_556 VGND VGND VPWR VPWR sky130_fd_sc_hd__decap_3
XFILLER_43_567 VGND VGND VPWR VPWR sky130_fd_sc_hd__decap_3
XFILLER_30_206 VGND VGND VPWR VPWR sky130_fd_sc_hd__decap_3
XTAP_TAPCELL_ROW_13_404 VGND VPWR sky130_fd_sc_hd__tapvpwrvgnd_1
XFILLER_90_67 VGND VGND VPWR VPWR sky130_fd_sc_hd__decap_3
XTAP_TAPCELL_ROW_41_746 VGND VPWR sky130_fd_sc_hd__tapvpwrvgnd_1
XFILLER_23_72 VGND VGND VPWR VPWR sky130_fd_sc_hd__decap_3
XFILLER_99_54 VGND VGND VPWR VPWR sky130_fd_sc_hd__fill_2
XFILLER_109_396 VGND VGND VPWR VPWR sky130_fd_sc_hd__decap_3
XFILLER_99_87 VGND VGND VPWR VPWR sky130_fd_sc_hd__decap_3
XFILLER_3_641 VGND VGND VPWR VPWR sky130_fd_sc_hd__decap_3
XFILLER_112_539 VGND VGND VPWR VPWR sky130_fd_sc_hd__decap_3
XFILLER_97_228 VGND VGND VPWR VPWR sky130_fd_sc_hd__decap_3
XFILLER_66_604 VGND VGND VPWR VPWR sky130_fd_sc_hd__decap_3
XFILLER_78_442 VGND VGND VPWR VPWR sky130_fd_sc_hd__decap_3
XFILLER_78_486 VGND VGND VPWR VPWR sky130_fd_sc_hd__decap_3
XFILLER_17_6 VGND VGND VPWR VPWR sky130_fd_sc_hd__decap_3
XFILLER_65_125 VGND VGND VPWR VPWR sky130_fd_sc_hd__fill_2
XFILLER_65_147 VGND VGND VPWR VPWR sky130_fd_sc_hd__decap_3
XFILLER_66_648 VGND VGND VPWR VPWR sky130_fd_sc_hd__decap_3
XTAP_TAPCELL_ROW_49_835 VGND VPWR sky130_fd_sc_hd__tapvpwrvgnd_1
XFILLER_0_32 VGND VGND VPWR VPWR sky130_fd_sc_hd__decap_3
XFILLER_46_350 VGND VGND VPWR VPWR sky130_fd_sc_hd__fill_1
XFILLER_65_169 VGND VGND VPWR VPWR sky130_fd_sc_hd__decap_3
XFILLER_80_106 VGND VGND VPWR VPWR sky130_fd_sc_hd__decap_3
XFILLER_81_629 VGND VGND VPWR VPWR sky130_fd_sc_hd__decap_3
XFILLER_93_467 VGND VGND VPWR VPWR sky130_fd_sc_hd__decap_3
XFILLER_0_65 VGND VGND VPWR VPWR sky130_fd_sc_hd__decap_3
XFILLER_46_394 VGND VGND VPWR VPWR sky130_fd_sc_hd__decap_3
XFILLER_61_320 VGND VGND VPWR VPWR sky130_fd_sc_hd__decap_3
XFILLER_73_180 VGND VGND VPWR VPWR sky130_fd_sc_hd__decap_3
XFILLER_74_681 VGND VGND VPWR VPWR sky130_fd_sc_hd__decap_3
XFILLER_80_139 VGND VGND VPWR VPWR sky130_fd_sc_hd__fill_1
XFILLER_0_98 VGND VGND VPWR VPWR sky130_fd_sc_hd__decap_3
X_4800_ _7002_/Q _4826_/A _7003_/Q VGND VGND VPWR VPWR _4801_/B sky130_fd_sc_hd__a21oi_2
XFILLER_21_228 VGND VGND VPWR VPWR sky130_fd_sc_hd__decap_3
XFILLER_9_30 VGND VGND VPWR VPWR sky130_fd_sc_hd__decap_3
X_4731_ _4731_/A _4731_/B VGND VGND VPWR VPWR _7007_/D sky130_fd_sc_hd__and2_2
XFILLER_9_63 VGND VGND VPWR VPWR sky130_fd_sc_hd__decap_3
X_4662_ _4969_/B _4457_/X _4660_/X _4811_/C _4040_/Y VGND VGND VPWR VPWR _4662_/Y
+ sky130_fd_sc_hd__a221oi_2
X_6401_ _6562_/A VGND VGND VPWR VPWR _6401_/Y sky130_fd_sc_hd__inv_2
X_3613_ _3603_/Y _3606_/X _3612_/X VGND VGND VPWR VPWR _3614_/B sky130_fd_sc_hd__a21oi_2
X_7381_ _7384_/CLK _7381_/D _6661_/Y VGND VGND VPWR VPWR _7381_/Q sky130_fd_sc_hd__dfrtp_2
Xhold903 _7099_/Q VGND VGND VPWR VPWR _7099_/D sky130_fd_sc_hd__dlygate4sd3_1
X_4593_ _7284_/Q _4595_/B VGND VGND VPWR VPWR _7284_/D sky130_fd_sc_hd__and2_2
XFILLER_115_311 VGND VGND VPWR VPWR sky130_fd_sc_hd__decap_3
Xhold914 _6688_/Q VGND VGND VPWR VPWR hold914/X sky130_fd_sc_hd__dlygate4sd3_1
Xhold925 _7014_/Q VGND VGND VPWR VPWR _5628_/A sky130_fd_sc_hd__dlygate4sd3_1
Xhold936 _5688_/X VGND VGND VPWR VPWR _6694_/D sky130_fd_sc_hd__dlygate4sd3_1
X_6332_ _6684_/A VGND VGND VPWR VPWR _6332_/Y sky130_fd_sc_hd__inv_2
X_3544_ _3544_/A _3544_/B VGND VGND VPWR VPWR _3635_/A sky130_fd_sc_hd__nor2_2
XFILLER_103_517 VGND VGND VPWR VPWR sky130_fd_sc_hd__fill_2
XFILLER_88_206 VGND VGND VPWR VPWR sky130_fd_sc_hd__decap_3
Xhold969 _7382_/Q VGND VGND VPWR VPWR hold969/X sky130_fd_sc_hd__dlygate4sd3_1
Xhold958 _7188_/Q VGND VGND VPWR VPWR hold958/X sky130_fd_sc_hd__dlygate4sd3_1
Xhold947 _6714_/Q VGND VGND VPWR VPWR hold947/X sky130_fd_sc_hd__dlygate4sd3_1
X_6263_ _6385_/A VGND VGND VPWR VPWR _6263_/Y sky130_fd_sc_hd__inv_2
X_3475_ _7248_/Q _3358_/X _3472_/X _3474_/X VGND VGND VPWR VPWR _3502_/A sky130_fd_sc_hd__a211oi_2
XFILLER_115_388 VGND VGND VPWR VPWR sky130_fd_sc_hd__fill_1
XFILLER_57_626 VGND VGND VPWR VPWR sky130_fd_sc_hd__decap_3
XFILLER_69_475 VGND VGND VPWR VPWR sky130_fd_sc_hd__fill_1
XFILLER_69_486 VGND VGND VPWR VPWR sky130_fd_sc_hd__fill_1
X_5145_ _5145_/A _3500_/Y VGND VGND VPWR VPWR _5145_/X sky130_fd_sc_hd__or2b_2
XFILLER_111_594 VGND VGND VPWR VPWR sky130_fd_sc_hd__decap_3
XFILLER_56_147 VGND VGND VPWR VPWR sky130_fd_sc_hd__fill_1
XFILLER_57_659 VGND VGND VPWR VPWR sky130_fd_sc_hd__decap_3
XFILLER_84_445 VGND VGND VPWR VPWR sky130_fd_sc_hd__decap_3
XFILLER_44_309 VGND VGND VPWR VPWR sky130_fd_sc_hd__decap_3
XFILLER_56_169 VGND VGND VPWR VPWR sky130_fd_sc_hd__decap_3
XFILLER_44_27 VGND VGND VPWR VPWR sky130_fd_sc_hd__fill_1
XFILLER_44_38 VGND VGND VPWR VPWR sky130_fd_sc_hd__decap_3
XFILLER_52_342 VGND VGND VPWR VPWR sky130_fd_sc_hd__decap_3
XFILLER_12_206 VGND VGND VPWR VPWR sky130_fd_sc_hd__decap_3
XFILLER_25_578 VGND VGND VPWR VPWR sky130_fd_sc_hd__fill_2
XFILLER_80_684 VGND VGND VPWR VPWR sky130_fd_sc_hd__decap_3
XFILLER_100_44 VGND VGND VPWR VPWR sky130_fd_sc_hd__decap_3
XFILLER_12_239 VGND VGND VPWR VPWR sky130_fd_sc_hd__fill_2
X_4929_ _4908_/B _4928_/Y _5015_/A VGND VGND VPWR VPWR _4929_/Y sky130_fd_sc_hd__o21ai_2
XFILLER_100_88 VGND VGND VPWR VPWR sky130_fd_sc_hd__fill_1
XFILLER_60_26 VGND VGND VPWR VPWR sky130_fd_sc_hd__fill_2
XFILLER_20_272 VGND VGND VPWR VPWR sky130_fd_sc_hd__decap_3
XFILLER_106_333 VGND VGND VPWR VPWR sky130_fd_sc_hd__decap_3
XFILLER_109_42 VGND VGND VPWR VPWR sky130_fd_sc_hd__decap_3
XFILLER_4_427 VGND VGND VPWR VPWR sky130_fd_sc_hd__decap_3
XFILLER_4_449 VGND VGND VPWR VPWR sky130_fd_sc_hd__decap_3
XFILLER_109_75 VGND VGND VPWR VPWR sky130_fd_sc_hd__decap_3
XFILLER_69_24 VGND VGND VPWR VPWR sky130_fd_sc_hd__fill_2
XFILLER_69_57 VGND VGND VPWR VPWR sky130_fd_sc_hd__fill_1
XFILLER_106_377 VGND VGND VPWR VPWR sky130_fd_sc_hd__fill_2
XFILLER_48_615 VGND VGND VPWR VPWR sky130_fd_sc_hd__decap_3
XFILLER_85_23 VGND VGND VPWR VPWR sky130_fd_sc_hd__decap_3
XFILLER_87_261 VGND VGND VPWR VPWR sky130_fd_sc_hd__decap_3
XFILLER_102_583 VGND VGND VPWR VPWR sky130_fd_sc_hd__decap_3
XFILLER_48_648 VGND VGND VPWR VPWR sky130_fd_sc_hd__decap_3
XFILLER_75_423 VGND VGND VPWR VPWR sky130_fd_sc_hd__decap_3
XFILLER_85_67 VGND VGND VPWR VPWR sky130_fd_sc_hd__decap_3
XTAP_TAPCELL_ROW_89_1324 VGND VPWR sky130_fd_sc_hd__tapvpwrvgnd_1
XFILLER_18_50 VGND VGND VPWR VPWR sky130_fd_sc_hd__decap_3
XFILLER_47_169 VGND VGND VPWR VPWR sky130_fd_sc_hd__decap_3
XFILLER_63_629 VGND VGND VPWR VPWR sky130_fd_sc_hd__decap_3
XFILLER_75_467 VGND VGND VPWR VPWR sky130_fd_sc_hd__decap_3
XTAP_TAPCELL_ROW_46_805 VGND VPWR sky130_fd_sc_hd__tapvpwrvgnd_1
XFILLER_16_501 VGND VGND VPWR VPWR sky130_fd_sc_hd__fill_2
XFILLER_18_94 VGND VGND VPWR VPWR sky130_fd_sc_hd__decap_3
XFILLER_28_361 VGND VGND VPWR VPWR sky130_fd_sc_hd__decap_3
XFILLER_56_681 VGND VGND VPWR VPWR sky130_fd_sc_hd__decap_3
XFILLER_90_448 VGND VGND VPWR VPWR sky130_fd_sc_hd__decap_3
XFILLER_16_556 VGND VGND VPWR VPWR sky130_fd_sc_hd__decap_3
XFILLER_71_662 VGND VGND VPWR VPWR sky130_fd_sc_hd__decap_3
XFILLER_70_150 VGND VGND VPWR VPWR sky130_fd_sc_hd__fill_1
XFILLER_70_161 VGND VGND VPWR VPWR sky130_fd_sc_hd__decap_3
XFILLER_70_172 VGND VGND VPWR VPWR sky130_fd_sc_hd__decap_3
XFILLER_71_673 VGND VGND VPWR VPWR sky130_fd_sc_hd__decap_3
XTAP_TAPCELL_ROW_26_562 VGND VPWR sky130_fd_sc_hd__tapvpwrvgnd_1
XFILLER_31_559 VGND VGND VPWR VPWR sky130_fd_sc_hd__fill_1
XFILLER_34_82 VGND VGND VPWR VPWR sky130_fd_sc_hd__fill_2
XFILLER_86_9 VGND VGND VPWR VPWR sky130_fd_sc_hd__fill_1
XFILLER_7_221 VGND VGND VPWR VPWR sky130_fd_sc_hd__decap_3
XFILLER_7_243 VGND VGND VPWR VPWR sky130_fd_sc_hd__decap_3
XFILLER_7_298 VGND VGND VPWR VPWR sky130_fd_sc_hd__decap_3
XFILLER_112_303 VGND VGND VPWR VPWR sky130_fd_sc_hd__decap_3
XFILLER_112_358 VGND VGND VPWR VPWR sky130_fd_sc_hd__decap_3
XFILLER_59_90 VGND VGND VPWR VPWR sky130_fd_sc_hd__decap_3
XFILLER_78_250 VGND VGND VPWR VPWR sky130_fd_sc_hd__fill_2
XFILLER_78_272 VGND VGND VPWR VPWR sky130_fd_sc_hd__decap_3
XFILLER_85_209 VGND VGND VPWR VPWR sky130_fd_sc_hd__decap_3
XFILLER_15_3 VGND VGND VPWR VPWR sky130_fd_sc_hd__decap_3
XFILLER_39_659 VGND VGND VPWR VPWR sky130_fd_sc_hd__decap_3
XFILLER_66_434 VGND VGND VPWR VPWR sky130_fd_sc_hd__decap_3
XFILLER_78_294 VGND VGND VPWR VPWR sky130_fd_sc_hd__fill_1
XFILLER_93_231 VGND VGND VPWR VPWR sky130_fd_sc_hd__decap_3
XFILLER_26_309 VGND VGND VPWR VPWR sky130_fd_sc_hd__decap_3
XFILLER_38_147 VGND VGND VPWR VPWR sky130_fd_sc_hd__decap_3
XFILLER_54_607 VGND VGND VPWR VPWR sky130_fd_sc_hd__decap_3
XFILLER_66_467 VGND VGND VPWR VPWR sky130_fd_sc_hd__decap_3
X_6950_ _6966_/CLK _6950_/D VGND VGND VPWR VPWR _6950_/Q sky130_fd_sc_hd__dfxtp_2
XFILLER_19_383 VGND VGND VPWR VPWR sky130_fd_sc_hd__decap_3
XFILLER_53_106 VGND VGND VPWR VPWR sky130_fd_sc_hd__decap_3
XTAP_TAPCELL_ROW_109_1560 VGND VPWR sky130_fd_sc_hd__tapvpwrvgnd_1
XFILLER_46_180 VGND VGND VPWR VPWR sky130_fd_sc_hd__decap_3
XFILLER_62_651 VGND VGND VPWR VPWR sky130_fd_sc_hd__decap_3
X_6881_ _6966_/CLK _6881_/D VGND VGND VPWR VPWR _6881_/Q sky130_fd_sc_hd__dfxtp_2
XFILLER_61_150 VGND VGND VPWR VPWR sky130_fd_sc_hd__decap_3
XFILLER_62_684 VGND VGND VPWR VPWR sky130_fd_sc_hd__decap_3
XFILLER_61_172 VGND VGND VPWR VPWR sky130_fd_sc_hd__decap_3
XPHY_EDGE_ROW_101_Left_218 VGND VGND VPWR VPWR sky130_fd_sc_hd__decap_3
XFILLER_107_119 VGND VGND VPWR VPWR sky130_fd_sc_hd__decap_3
XFILLER_30_29 VGND VGND VPWR VPWR sky130_fd_sc_hd__decap_3
X_4645_ _4633_/X _4903_/B _4644_/X _4096_/A VGND VGND VPWR VPWR _4646_/B sky130_fd_sc_hd__o211a_2
XFILLER_116_620 VGND VGND VPWR VPWR sky130_fd_sc_hd__decap_3
X_7364_ _7365_/CLK _7364_/D _6644_/Y VGND VGND VPWR VPWR _7364_/Q sky130_fd_sc_hd__dfrtp_2
Xhold700 _6747_/Q VGND VGND VPWR VPWR _6747_/D sky130_fd_sc_hd__dlygate4sd3_1
Xhold711 _6966_/Q VGND VGND VPWR VPWR _6966_/D sky130_fd_sc_hd__dlygate4sd3_1
XFILLER_1_408 VGND VGND VPWR VPWR sky130_fd_sc_hd__decap_3
Xhold722 _6744_/Q VGND VGND VPWR VPWR _6744_/D sky130_fd_sc_hd__dlygate4sd3_1
Xhold733 _6750_/Q VGND VGND VPWR VPWR _6750_/D sky130_fd_sc_hd__dlygate4sd3_1
Xhold744 _6795_/Q VGND VGND VPWR VPWR _6795_/D sky130_fd_sc_hd__dlygate4sd3_1
Xhold755 _6766_/Q VGND VGND VPWR VPWR _6766_/D sky130_fd_sc_hd__dlygate4sd3_1
X_6315_ _6637_/A VGND VGND VPWR VPWR _6315_/Y sky130_fd_sc_hd__inv_2
X_3527_ _3527_/A _3427_/B VGND VGND VPWR VPWR _4614_/A sky130_fd_sc_hd__nor2b_2
XFILLER_103_325 VGND VGND VPWR VPWR sky130_fd_sc_hd__fill_2
XFILLER_115_152 VGND VGND VPWR VPWR sky130_fd_sc_hd__decap_3
X_7295_ _7397_/CLK _7295_/D _6575_/Y VGND VGND VPWR VPWR _7295_/Q sky130_fd_sc_hd__dfrtp_2
Xhold766 _6759_/Q VGND VGND VPWR VPWR _6759_/D sky130_fd_sc_hd__dlygate4sd3_1
Xhold777 _6976_/Q VGND VGND VPWR VPWR _6976_/D sky130_fd_sc_hd__dlygate4sd3_1
Xhold788 _6831_/Q VGND VGND VPWR VPWR _6831_/D sky130_fd_sc_hd__dlygate4sd3_1
XTAP_TAPCELL_ROW_73_1125 VGND VPWR sky130_fd_sc_hd__tapvpwrvgnd_1
XFILLER_115_196 VGND VGND VPWR VPWR sky130_fd_sc_hd__decap_3
XFILLER_39_27 VGND VGND VPWR VPWR sky130_fd_sc_hd__decap_3
XFILLER_89_559 VGND VGND VPWR VPWR sky130_fd_sc_hd__fill_1
Xhold799 _6862_/Q VGND VGND VPWR VPWR _6862_/D sky130_fd_sc_hd__dlygate4sd3_1
X_3458_ _3544_/A _3506_/B VGND VGND VPWR VPWR _3458_/Y sky130_fd_sc_hd__nor2_2
XPHY_EDGE_ROW_110_Left_227 VGND VGND VPWR VPWR sky130_fd_sc_hd__decap_3
XFILLER_39_49 VGND VGND VPWR VPWR sky130_fd_sc_hd__decap_3
XFILLER_97_570 VGND VGND VPWR VPWR sky130_fd_sc_hd__fill_2
X_3389_ _7347_/Q _4338_/B1 _3384_/X _3556_/A VGND VGND VPWR VPWR _3389_/X sky130_fd_sc_hd__a211o_2
XFILLER_29_125 VGND VGND VPWR VPWR sky130_fd_sc_hd__decap_3
XFILLER_57_445 VGND VGND VPWR VPWR sky130_fd_sc_hd__decap_3
XFILLER_69_272 VGND VGND VPWR VPWR sky130_fd_sc_hd__decap_3
X_5128_ _3733_/C _3904_/Y _4677_/B VGND VGND VPWR VPWR _5128_/Y sky130_fd_sc_hd__a21oi_2
XFILLER_29_169 VGND VGND VPWR VPWR sky130_fd_sc_hd__decap_3
XFILLER_55_15 VGND VGND VPWR VPWR sky130_fd_sc_hd__decap_3
XFILLER_84_253 VGND VGND VPWR VPWR sky130_fd_sc_hd__fill_1
XFILLER_45_629 VGND VGND VPWR VPWR sky130_fd_sc_hd__decap_3
XFILLER_55_48 VGND VGND VPWR VPWR sky130_fd_sc_hd__decap_3
X_5059_ _3833_/S _3859_/X _5662_/B VGND VGND VPWR VPWR _5059_/X sky130_fd_sc_hd__a21o_2
XFILLER_25_331 VGND VGND VPWR VPWR sky130_fd_sc_hd__decap_3
XFILLER_111_43 VGND VGND VPWR VPWR sky130_fd_sc_hd__decap_3
XFILLER_25_364 VGND VGND VPWR VPWR sky130_fd_sc_hd__decap_3
XFILLER_40_301 VGND VGND VPWR VPWR sky130_fd_sc_hd__decap_3
XFILLER_52_150 VGND VGND VPWR VPWR sky130_fd_sc_hd__decap_3
XFILLER_53_673 VGND VGND VPWR VPWR sky130_fd_sc_hd__decap_3
XTAP_TAPCELL_ROW_84_1265 VGND VPWR sky130_fd_sc_hd__tapvpwrvgnd_1
XTAP_TAPCELL_ROW_84_1254 VGND VPWR sky130_fd_sc_hd__tapvpwrvgnd_1
XFILLER_111_87 VGND VGND VPWR VPWR sky130_fd_sc_hd__decap_3
XFILLER_13_548 VGND VGND VPWR VPWR sky130_fd_sc_hd__decap_3
XFILLER_40_312 VGND VGND VPWR VPWR sky130_fd_sc_hd__decap_3
XFILLER_52_183 VGND VGND VPWR VPWR sky130_fd_sc_hd__decap_3
XFILLER_71_25 VGND VGND VPWR VPWR sky130_fd_sc_hd__decap_3
XFILLER_80_492 VGND VGND VPWR VPWR sky130_fd_sc_hd__decap_3
XTAP_TAPCELL_ROW_23_532 VGND VPWR sky130_fd_sc_hd__tapvpwrvgnd_1
XTAP_TAPCELL_ROW_51_863 VGND VPWR sky130_fd_sc_hd__tapvpwrvgnd_1
XFILLER_40_389 VGND VGND VPWR VPWR sky130_fd_sc_hd__decap_3
XPHY_EDGE_ROW_109_Right_109 VGND VGND VPWR VPWR sky130_fd_sc_hd__decap_3
XFILLER_107_653 VGND VGND VPWR VPWR sky130_fd_sc_hd__decap_3
XFILLER_4_246 VGND VGND VPWR VPWR sky130_fd_sc_hd__decap_3
XFILLER_106_163 VGND VGND VPWR VPWR sky130_fd_sc_hd__decap_3
XFILLER_20_62 VGND VGND VPWR VPWR sky130_fd_sc_hd__decap_3
XFILLER_96_11 VGND VGND VPWR VPWR sky130_fd_sc_hd__decap_3
XTAP_TAPCELL_ROW_95_1394 VGND VPWR sky130_fd_sc_hd__tapvpwrvgnd_1
XFILLER_0_430 VGND VGND VPWR VPWR sky130_fd_sc_hd__decap_3
XFILLER_106_185 VGND VGND VPWR VPWR sky130_fd_sc_hd__decap_3
XFILLER_96_44 VGND VGND VPWR VPWR sky130_fd_sc_hd__decap_3
XFILLER_0_452 VGND VGND VPWR VPWR sky130_fd_sc_hd__decap_3
XFILLER_48_401 VGND VGND VPWR VPWR sky130_fd_sc_hd__fill_1
XFILLER_102_380 VGND VGND VPWR VPWR sky130_fd_sc_hd__decap_3
XFILLER_29_60 VGND VGND VPWR VPWR sky130_fd_sc_hd__decap_3
XFILLER_48_434 VGND VGND VPWR VPWR sky130_fd_sc_hd__decap_3
XFILLER_48_445 VGND VGND VPWR VPWR sky130_fd_sc_hd__decap_3
XFILLER_88_592 VGND VGND VPWR VPWR sky130_fd_sc_hd__decap_3
XFILLER_96_88 VGND VGND VPWR VPWR sky130_fd_sc_hd__decap_3
XTAP_TAPCELL_ROW_59_963 VGND VPWR sky130_fd_sc_hd__tapvpwrvgnd_1
Xplace404 _4532_/S VGND VGND VPWR VPWR _4534_/S sky130_fd_sc_hd__buf_2
XFILLER_28_180 VGND VGND VPWR VPWR sky130_fd_sc_hd__decap_3
XFILLER_44_651 VGND VGND VPWR VPWR sky130_fd_sc_hd__decap_3
XFILLER_90_256 VGND VGND VPWR VPWR sky130_fd_sc_hd__decap_3
Xplace415 _3380_/Y VGND VGND VPWR VPWR _4419_/B1 sky130_fd_sc_hd__buf_2
Xplace426 _4268_/A2 VGND VGND VPWR VPWR _3973_/S sky130_fd_sc_hd__buf_2
Xplace437 _3341_/A VGND VGND VPWR VPWR _5156_/S sky130_fd_sc_hd__buf_2
XTAP_TAPCELL_ROW_3_290 VGND VPWR sky130_fd_sc_hd__tapvpwrvgnd_1
XFILLER_44_684 VGND VGND VPWR VPWR sky130_fd_sc_hd__decap_3
XFILLER_45_81 VGND VGND VPWR VPWR sky130_fd_sc_hd__decap_3
XFILLER_50_109 VGND VGND VPWR VPWR sky130_fd_sc_hd__decap_3
Xplace448 _3318_/B VGND VGND VPWR VPWR _4469_/A3 sky130_fd_sc_hd__buf_2
Xplace459 _6979_/Q VGND VGND VPWR VPWR _3403_/A sky130_fd_sc_hd__buf_2
XFILLER_43_172 VGND VGND VPWR VPWR sky130_fd_sc_hd__fill_1
XFILLER_71_481 VGND VGND VPWR VPWR sky130_fd_sc_hd__fill_2
XFILLER_71_492 VGND VGND VPWR VPWR sky130_fd_sc_hd__decap_3
XFILLER_84_6 VGND VGND VPWR VPWR sky130_fd_sc_hd__decap_3
XFILLER_12_570 VGND VGND VPWR VPWR sky130_fd_sc_hd__fill_1
XANTENNA_2 _5646_/Y VGND VGND VPWR VPWR sky130_fd_sc_hd__diode_2
X_4430_ _7239_/Q _4430_/A2 _4430_/B1 _7175_/Q _4429_/X VGND VGND VPWR VPWR _4430_/X
+ sky130_fd_sc_hd__a221o_2
XFILLER_6_53 VGND VGND VPWR VPWR sky130_fd_sc_hd__decap_3
XFILLER_112_100 VGND VGND VPWR VPWR sky130_fd_sc_hd__decap_3
XFILLER_113_612 VGND VGND VPWR VPWR sky130_fd_sc_hd__decap_3
XFILLER_113_623 VGND VGND VPWR VPWR sky130_fd_sc_hd__decap_3
XFILLER_6_97 VGND VGND VPWR VPWR sky130_fd_sc_hd__decap_3
X_4361_ _4361_/A _4619_/B _5101_/B _5073_/A VGND VGND VPWR VPWR _4361_/X sky130_fd_sc_hd__and4_2
XFILLER_98_323 VGND VGND VPWR VPWR sky130_fd_sc_hd__decap_3
XFILLER_112_133 VGND VGND VPWR VPWR sky130_fd_sc_hd__decap_3
XFILLER_113_656 VGND VGND VPWR VPWR sky130_fd_sc_hd__decap_3
XFILLER_3_290 VGND VGND VPWR VPWR sky130_fd_sc_hd__decap_3
X_7080_ _7266_/CLK _7080_/D _6360_/Y VGND VGND VPWR VPWR _7080_/Q sky130_fd_sc_hd__dfrtp_2
X_4292_ _4292_/A _4292_/B _4292_/C VGND VGND VPWR VPWR _4292_/X sky130_fd_sc_hd__and3_2
X_3312_ _3330_/A _4467_/A _3519_/B _3310_/Y _5671_/A VGND VGND VPWR VPWR _5646_/A
+ sky130_fd_sc_hd__a311o_2
XFILLER_98_345 VGND VGND VPWR VPWR sky130_fd_sc_hd__decap_3
XFILLER_112_144 VGND VGND VPWR VPWR sky130_fd_sc_hd__decap_3
XFILLER_112_177 VGND VGND VPWR VPWR sky130_fd_sc_hd__decap_3
XFILLER_58_209 VGND VGND VPWR VPWR sky130_fd_sc_hd__decap_3
XFILLER_98_389 VGND VGND VPWR VPWR sky130_fd_sc_hd__decap_3
XFILLER_39_412 VGND VGND VPWR VPWR sky130_fd_sc_hd__decap_3
XFILLER_66_253 VGND VGND VPWR VPWR sky130_fd_sc_hd__decap_3
XFILLER_94_551 VGND VGND VPWR VPWR sky130_fd_sc_hd__decap_3
XFILLER_54_404 VGND VGND VPWR VPWR sky130_fd_sc_hd__fill_2
XFILLER_66_286 VGND VGND VPWR VPWR sky130_fd_sc_hd__fill_2
XFILLER_66_297 VGND VGND VPWR VPWR sky130_fd_sc_hd__decap_3
XFILLER_94_584 VGND VGND VPWR VPWR sky130_fd_sc_hd__decap_3
XFILLER_81_234 VGND VGND VPWR VPWR sky130_fd_sc_hd__decap_3
XFILLER_81_256 VGND VGND VPWR VPWR sky130_fd_sc_hd__decap_3
X_6933_ _7230_/CLK _6933_/D VGND VGND VPWR VPWR _6933_/Q sky130_fd_sc_hd__dfxtp_2
XFILLER_34_150 VGND VGND VPWR VPWR sky130_fd_sc_hd__decap_3
XFILLER_81_289 VGND VGND VPWR VPWR sky130_fd_sc_hd__decap_3
X_6864_ _6959_/CLK _6864_/D VGND VGND VPWR VPWR _6864_/Q sky130_fd_sc_hd__dfxtp_2
XFILLER_34_183 VGND VGND VPWR VPWR sky130_fd_sc_hd__decap_3
XFILLER_50_621 VGND VGND VPWR VPWR sky130_fd_sc_hd__decap_3
XFILLER_62_492 VGND VGND VPWR VPWR sky130_fd_sc_hd__fill_2
XFILLER_22_356 VGND VGND VPWR VPWR sky130_fd_sc_hd__decap_3
XFILLER_50_654 VGND VGND VPWR VPWR sky130_fd_sc_hd__decap_3
X_6795_ _7230_/CLK _6795_/D VGND VGND VPWR VPWR _6795_/Q sky130_fd_sc_hd__dfxtp_2
XFILLER_41_17 VGND VGND VPWR VPWR sky130_fd_sc_hd__decap_3
XFILLER_50_687 VGND VGND VPWR VPWR sky130_fd_sc_hd__decap_3
X_4628_ _4628_/A VGND VGND VPWR VPWR _4629_/A sky130_fd_sc_hd__inv_2
XFILLER_116_461 VGND VGND VPWR VPWR sky130_fd_sc_hd__decap_3
XFILLER_116_483 VGND VGND VPWR VPWR sky130_fd_sc_hd__decap_3
XFILLER_89_312 VGND VGND VPWR VPWR sky130_fd_sc_hd__decap_3
X_7347_ clkload4/A _7347_/D _6627_/Y VGND VGND VPWR VPWR _7347_/Q sky130_fd_sc_hd__dfrtp_2
X_4559_ _4559_/A _4561_/B VGND VGND VPWR VPWR _7301_/D sky130_fd_sc_hd__and2_2
XFILLER_104_645 VGND VGND VPWR VPWR sky130_fd_sc_hd__decap_3
X_7278_ _7372_/CLK _7278_/D _6558_/Y VGND VGND VPWR VPWR _7278_/Q sky130_fd_sc_hd__dfrtp_2
Xhold585 _6884_/Q VGND VGND VPWR VPWR _6884_/D sky130_fd_sc_hd__dlygate4sd3_1
Xhold596 _6880_/Q VGND VGND VPWR VPWR _6880_/D sky130_fd_sc_hd__dlygate4sd3_1
XFILLER_103_144 VGND VGND VPWR VPWR sky130_fd_sc_hd__decap_3
XFILLER_104_678 VGND VGND VPWR VPWR sky130_fd_sc_hd__decap_3
XFILLER_106_21 VGND VGND VPWR VPWR sky130_fd_sc_hd__decap_3
XFILLER_106_32 VGND VGND VPWR VPWR sky130_fd_sc_hd__decap_3
XFILLER_77_529 VGND VGND VPWR VPWR sky130_fd_sc_hd__decap_3
XFILLER_106_65 VGND VGND VPWR VPWR sky130_fd_sc_hd__decap_3
XFILLER_57_220 VGND VGND VPWR VPWR sky130_fd_sc_hd__decap_3
XFILLER_57_242 VGND VGND VPWR VPWR sky130_fd_sc_hd__decap_3
XFILLER_66_69 VGND VGND VPWR VPWR sky130_fd_sc_hd__decap_3
XFILLER_18_629 VGND VGND VPWR VPWR sky130_fd_sc_hd__decap_3
XFILLER_85_573 VGND VGND VPWR VPWR sky130_fd_sc_hd__decap_3
XTAP_TAPCELL_ROW_56_922 VGND VPWR sky130_fd_sc_hd__tapvpwrvgnd_1
XFILLER_72_223 VGND VGND VPWR VPWR sky130_fd_sc_hd__decap_3
XFILLER_60_418 VGND VGND VPWR VPWR sky130_fd_sc_hd__fill_2
XFILLER_72_289 VGND VGND VPWR VPWR sky130_fd_sc_hd__decap_3
XFILLER_82_35 VGND VGND VPWR VPWR sky130_fd_sc_hd__decap_3
XFILLER_13_312 VGND VGND VPWR VPWR sky130_fd_sc_hd__fill_2
XFILLER_25_172 VGND VGND VPWR VPWR sky130_fd_sc_hd__decap_3
XFILLER_25_183 VGND VGND VPWR VPWR sky130_fd_sc_hd__fill_1
XFILLER_25_194 VGND VGND VPWR VPWR sky130_fd_sc_hd__decap_3
XFILLER_82_68 VGND VGND VPWR VPWR sky130_fd_sc_hd__decap_3
XFILLER_13_345 VGND VGND VPWR VPWR sky130_fd_sc_hd__decap_3
XFILLER_15_51 VGND VGND VPWR VPWR sky130_fd_sc_hd__decap_3
XFILLER_15_84 VGND VGND VPWR VPWR sky130_fd_sc_hd__decap_3
XFILLER_40_120 VGND VGND VPWR VPWR sky130_fd_sc_hd__decap_3
XFILLER_41_665 VGND VGND VPWR VPWR sky130_fd_sc_hd__decap_3
XFILLER_41_676 VGND VGND VPWR VPWR sky130_fd_sc_hd__decap_3
XFILLER_13_389 VGND VGND VPWR VPWR sky130_fd_sc_hd__decap_3
XFILLER_40_186 VGND VGND VPWR VPWR sky130_fd_sc_hd__decap_3
XFILLER_9_327 VGND VGND VPWR VPWR sky130_fd_sc_hd__decap_3
XTAP_TAPCELL_ROW_97_1412 VGND VPWR sky130_fd_sc_hd__tapvpwrvgnd_1
XFILLER_5_500 VGND VGND VPWR VPWR sky130_fd_sc_hd__decap_3
XFILLER_31_72 VGND VGND VPWR VPWR sky130_fd_sc_hd__decap_3
XFILLER_31_83 VGND VGND VPWR VPWR sky130_fd_sc_hd__decap_3
XFILLER_107_483 VGND VGND VPWR VPWR sky130_fd_sc_hd__decap_3
XFILLER_99_109 VGND VGND VPWR VPWR sky130_fd_sc_hd__decap_3
XFILLER_49_9 VGND VGND VPWR VPWR sky130_fd_sc_hd__decap_3
XFILLER_110_604 VGND VGND VPWR VPWR sky130_fd_sc_hd__decap_3
XFILLER_0_271 VGND VGND VPWR VPWR sky130_fd_sc_hd__decap_3
XFILLER_110_637 VGND VGND VPWR VPWR sky130_fd_sc_hd__decap_3
XFILLER_110_648 VGND VGND VPWR VPWR sky130_fd_sc_hd__decap_3
XFILLER_95_337 VGND VGND VPWR VPWR sky130_fd_sc_hd__decap_3
XFILLER_48_253 VGND VGND VPWR VPWR sky130_fd_sc_hd__decap_3
XFILLER_76_551 VGND VGND VPWR VPWR sky130_fd_sc_hd__decap_3
XFILLER_48_286 VGND VGND VPWR VPWR sky130_fd_sc_hd__decap_3
XFILLER_48_297 VGND VGND VPWR VPWR sky130_fd_sc_hd__decap_3
XFILLER_56_80 VGND VGND VPWR VPWR sky130_fd_sc_hd__decap_3
XFILLER_91_543 VGND VGND VPWR VPWR sky130_fd_sc_hd__decap_3
XFILLER_16_150 VGND VGND VPWR VPWR sky130_fd_sc_hd__decap_3
XFILLER_17_673 VGND VGND VPWR VPWR sky130_fd_sc_hd__fill_2
XFILLER_51_429 VGND VGND VPWR VPWR sky130_fd_sc_hd__decap_3
XFILLER_63_278 VGND VGND VPWR VPWR sky130_fd_sc_hd__fill_2
XFILLER_91_576 VGND VGND VPWR VPWR sky130_fd_sc_hd__fill_2
XFILLER_32_621 VGND VGND VPWR VPWR sky130_fd_sc_hd__decap_3
Xplace289 _3656_/Y VGND VGND VPWR VPWR _3893_/B1 sky130_fd_sc_hd__buf_2
Xplace278 _3912_/A2 VGND VGND VPWR VPWR _3902_/A2 sky130_fd_sc_hd__buf_2
Xplace267 _3665_/X VGND VGND VPWR VPWR _3891_/B1 sky130_fd_sc_hd__buf_2
XFILLER_31_164 VGND VGND VPWR VPWR sky130_fd_sc_hd__decap_3
XFILLER_31_175 VGND VGND VPWR VPWR sky130_fd_sc_hd__decap_3
XFILLER_32_687 VGND VGND VPWR VPWR sky130_fd_sc_hd__decap_3
XFILLER_72_90 VGND VGND VPWR VPWR sky130_fd_sc_hd__decap_3
XFILLER_82_3 VGND VGND VPWR VPWR sky130_fd_sc_hd__decap_3
X_6580_ _6610_/A VGND VGND VPWR VPWR _6580_/Y sky130_fd_sc_hd__inv_2
X_5600_ _5600_/A _5634_/B VGND VGND VPWR VPWR _7027_/D sky130_fd_sc_hd__and2_2
X_3792_ hold960/X _3909_/A2 _4961_/A VGND VGND VPWR VPWR _7392_/D sky130_fd_sc_hd__a21o_2
XFILLER_8_382 VGND VGND VPWR VPWR sky130_fd_sc_hd__decap_3
X_7201_ _7267_/CLK _7201_/D _6481_/Y VGND VGND VPWR VPWR _7201_/Q sky130_fd_sc_hd__dfrtp_2
X_4413_ _4413_/A VGND VGND VPWR VPWR _4787_/A sky130_fd_sc_hd__inv_2
XFILLER_113_431 VGND VGND VPWR VPWR sky130_fd_sc_hd__decap_3
X_7132_ _7358_/CLK _7132_/D _6412_/Y VGND VGND VPWR VPWR _7132_/Q sky130_fd_sc_hd__dfrtp_2
X_4344_ _4365_/A _4365_/B _4365_/C VGND VGND VPWR VPWR _4345_/B sky130_fd_sc_hd__a21bo_2
XFILLER_98_120 VGND VGND VPWR VPWR sky130_fd_sc_hd__decap_3
XFILLER_101_615 VGND VGND VPWR VPWR sky130_fd_sc_hd__fill_1
XFILLER_113_464 VGND VGND VPWR VPWR sky130_fd_sc_hd__decap_3
X_7063_ clkload9/A _7063_/D _6343_/Y VGND VGND VPWR VPWR _7063_/Q sky130_fd_sc_hd__dfrtp_2
XTAP_TAPCELL_ROW_6_319 VGND VPWR sky130_fd_sc_hd__tapvpwrvgnd_1
XFILLER_99_676 VGND VGND VPWR VPWR sky130_fd_sc_hd__decap_3
XFILLER_99_665 VGND VGND VPWR VPWR sky130_fd_sc_hd__decap_3
XFILLER_101_648 VGND VGND VPWR VPWR sky130_fd_sc_hd__decap_3
XFILLER_86_326 VGND VGND VPWR VPWR sky130_fd_sc_hd__decap_3
X_4275_ _4275_/A _4274_/Y VGND VGND VPWR VPWR _4987_/A sky130_fd_sc_hd__nor2b_2
XFILLER_98_197 VGND VGND VPWR VPWR sky130_fd_sc_hd__fill_1
XFILLER_100_136 VGND VGND VPWR VPWR sky130_fd_sc_hd__decap_3
XFILLER_100_147 VGND VGND VPWR VPWR sky130_fd_sc_hd__fill_2
XFILLER_39_231 VGND VGND VPWR VPWR sky130_fd_sc_hd__decap_3
XFILLER_39_264 VGND VGND VPWR VPWR sky130_fd_sc_hd__decap_3
XFILLER_67_595 VGND VGND VPWR VPWR sky130_fd_sc_hd__decap_3
XFILLER_82_521 VGND VGND VPWR VPWR sky130_fd_sc_hd__decap_3
XFILLER_82_554 VGND VGND VPWR VPWR sky130_fd_sc_hd__decap_3
XFILLER_42_418 VGND VGND VPWR VPWR sky130_fd_sc_hd__fill_2
XTAP_TAPCELL_ROW_68_1068 VGND VPWR sky130_fd_sc_hd__tapvpwrvgnd_1
XFILLER_54_289 VGND VGND VPWR VPWR sky130_fd_sc_hd__decap_3
X_6916_ _7387_/CLK _6916_/D VGND VGND VPWR VPWR _6916_/Q sky130_fd_sc_hd__dfxtp_2
XTAP_TAPCELL_ROW_81_1224 VGND VPWR sky130_fd_sc_hd__tapvpwrvgnd_1
XFILLER_52_27 VGND VGND VPWR VPWR sky130_fd_sc_hd__fill_1
XFILLER_52_38 VGND VGND VPWR VPWR sky130_fd_sc_hd__decap_3
X_6847_ _6978_/CLK _6847_/D VGND VGND VPWR VPWR _6847_/Q sky130_fd_sc_hd__dfxtp_2
XFILLER_10_326 VGND VGND VPWR VPWR sky130_fd_sc_hd__fill_2
X_6778_ _6965_/CLK _6778_/D VGND VGND VPWR VPWR _6778_/Q sky130_fd_sc_hd__dfxtp_2
XTAP_TAPCELL_ROW_61_980 VGND VPWR sky130_fd_sc_hd__tapvpwrvgnd_1
XFILLER_10_348 VGND VGND VPWR VPWR sky130_fd_sc_hd__fill_2
XFILLER_10_359 VGND VGND VPWR VPWR sky130_fd_sc_hd__decap_3
XFILLER_22_197 VGND VGND VPWR VPWR sky130_fd_sc_hd__decap_3
X_5729_ _7370_/Q hold947/X _5737_/S VGND VGND VPWR VPWR _6714_/D sky130_fd_sc_hd__mux2_2
XFILLER_108_214 VGND VGND VPWR VPWR sky130_fd_sc_hd__decap_3
XFILLER_108_247 VGND VGND VPWR VPWR sky130_fd_sc_hd__decap_3
XTAP_TAPCELL_ROW_79_1197 VGND VPWR sky130_fd_sc_hd__tapvpwrvgnd_1
XFILLER_89_131 VGND VGND VPWR VPWR sky130_fd_sc_hd__decap_3
XTAP_TAPCELL_ROW_92_1353 VGND VPWR sky130_fd_sc_hd__tapvpwrvgnd_1
XFILLER_77_24 VGND VGND VPWR VPWR sky130_fd_sc_hd__decap_3
XFILLER_89_153 VGND VGND VPWR VPWR sky130_fd_sc_hd__decap_3
XFILLER_104_497 VGND VGND VPWR VPWR sky130_fd_sc_hd__decap_3
XFILLER_77_315 VGND VGND VPWR VPWR sky130_fd_sc_hd__decap_3
XFILLER_77_326 VGND VGND VPWR VPWR sky130_fd_sc_hd__decap_3
XFILLER_77_337 VGND VGND VPWR VPWR sky130_fd_sc_hd__decap_3
XFILLER_77_57 VGND VGND VPWR VPWR sky130_fd_sc_hd__decap_3
XFILLER_89_186 VGND VGND VPWR VPWR sky130_fd_sc_hd__fill_2
XFILLER_89_197 VGND VGND VPWR VPWR sky130_fd_sc_hd__decap_3
XFILLER_77_348 VGND VGND VPWR VPWR sky130_fd_sc_hd__decap_3
XFILLER_92_307 VGND VGND VPWR VPWR sky130_fd_sc_hd__fill_1
XFILLER_100_681 VGND VGND VPWR VPWR sky130_fd_sc_hd__decap_3
XFILLER_45_201 VGND VGND VPWR VPWR sky130_fd_sc_hd__fill_2
XFILLER_92_318 VGND VGND VPWR VPWR sky130_fd_sc_hd__decap_3
XFILLER_93_12 VGND VGND VPWR VPWR sky130_fd_sc_hd__decap_3
Xhold1060 _7239_/Q VGND VGND VPWR VPWR _5177_/A sky130_fd_sc_hd__dlygate4sd3_1
XFILLER_45_234 VGND VGND VPWR VPWR sky130_fd_sc_hd__decap_3
XFILLER_73_521 VGND VGND VPWR VPWR sky130_fd_sc_hd__fill_1
XFILLER_73_554 VGND VGND VPWR VPWR sky130_fd_sc_hd__decap_3
XFILLER_93_45 VGND VGND VPWR VPWR sky130_fd_sc_hd__decap_3
Xhold1071 _7213_/Q VGND VGND VPWR VPWR _5234_/A0 sky130_fd_sc_hd__dlygate4sd3_1
Xhold1082 _7253_/Q VGND VGND VPWR VPWR _5126_/A0 sky130_fd_sc_hd__dlygate4sd3_1
Xhold1093 _7208_/Q VGND VGND VPWR VPWR _5243_/A0 sky130_fd_sc_hd__dlygate4sd3_1
XFILLER_45_267 VGND VGND VPWR VPWR sky130_fd_sc_hd__fill_2
XFILLER_26_61 VGND VGND VPWR VPWR sky130_fd_sc_hd__decap_3
XFILLER_26_83 VGND VGND VPWR VPWR sky130_fd_sc_hd__fill_1
XFILLER_33_429 VGND VGND VPWR VPWR sky130_fd_sc_hd__decap_3
XFILLER_14_665 VGND VGND VPWR VPWR sky130_fd_sc_hd__fill_1
XFILLER_26_94 VGND VGND VPWR VPWR sky130_fd_sc_hd__decap_3
XFILLER_13_153 VGND VGND VPWR VPWR sky130_fd_sc_hd__decap_3
XFILLER_13_175 VGND VGND VPWR VPWR sky130_fd_sc_hd__decap_3
XTAP_TAPCELL_ROW_31_619 VGND VPWR sky130_fd_sc_hd__tapvpwrvgnd_1
XTAP_TAPCELL_ROW_101_1460 VGND VPWR sky130_fd_sc_hd__tapvpwrvgnd_1
XFILLER_9_124 VGND VGND VPWR VPWR sky130_fd_sc_hd__decap_3
XFILLER_42_71 VGND VGND VPWR VPWR sky130_fd_sc_hd__decap_3
XFILLER_42_93 VGND VGND VPWR VPWR sky130_fd_sc_hd__fill_2
XTAP_TAPCELL_ROW_11_387 VGND VPWR sky130_fd_sc_hd__tapvpwrvgnd_1
XFILLER_114_206 VGND VGND VPWR VPWR sky130_fd_sc_hd__decap_3
XFILLER_114_239 VGND VGND VPWR VPWR sky130_fd_sc_hd__decap_3
XFILLER_47_6 VGND VGND VPWR VPWR sky130_fd_sc_hd__decap_3
XFILLER_5_396 VGND VGND VPWR VPWR sky130_fd_sc_hd__fill_2
XFILLER_3_21 VGND VGND VPWR VPWR sky130_fd_sc_hd__decap_3
XFILLER_68_304 VGND VGND VPWR VPWR sky130_fd_sc_hd__decap_3
XFILLER_3_54 VGND VGND VPWR VPWR sky130_fd_sc_hd__fill_2
XFILLER_68_337 VGND VGND VPWR VPWR sky130_fd_sc_hd__decap_3
XFILLER_95_123 VGND VGND VPWR VPWR sky130_fd_sc_hd__decap_3
XFILLER_3_87 VGND VGND VPWR VPWR sky130_fd_sc_hd__decap_3
XFILLER_95_156 VGND VGND VPWR VPWR sky130_fd_sc_hd__decap_3
XFILLER_96_668 VGND VGND VPWR VPWR sky130_fd_sc_hd__decap_3
X_4060_ _7084_/Q _4432_/A2 _4142_/A _4059_/X VGND VGND VPWR VPWR _4068_/A sky130_fd_sc_hd__o211a_2
XFILLER_76_370 VGND VGND VPWR VPWR sky130_fd_sc_hd__decap_3
XFILLER_95_178 VGND VGND VPWR VPWR sky130_fd_sc_hd__decap_3
XTAP_TAPCELL_ROW_39_719 VGND VPWR sky130_fd_sc_hd__tapvpwrvgnd_1
XFILLER_36_234 VGND VGND VPWR VPWR sky130_fd_sc_hd__decap_3
XFILLER_36_256 VGND VGND VPWR VPWR sky130_fd_sc_hd__decap_3
XFILLER_36_278 VGND VGND VPWR VPWR sky130_fd_sc_hd__decap_3
XFILLER_64_587 VGND VGND VPWR VPWR sky130_fd_sc_hd__fill_1
X_4962_ _6994_/Q _4977_/A VGND VGND VPWR VPWR _4963_/B sky130_fd_sc_hd__nor2_2
XTAP_TAPCELL_ROW_19_476 VGND VPWR sky130_fd_sc_hd__tapvpwrvgnd_1
X_6701_ _7392_/CLK _6701_/D VGND VGND VPWR VPWR _6701_/Q sky130_fd_sc_hd__dfxtp_2
X_4893_ _4928_/B _4943_/A _6996_/Q VGND VGND VPWR VPWR _4908_/B sky130_fd_sc_hd__o21a_2
X_3913_ _6857_/Q _3913_/A2 _3913_/B1 _6849_/Q _3912_/X VGND VGND VPWR VPWR _3913_/X
+ sky130_fd_sc_hd__a221o_2
X_6632_ _6632_/A VGND VGND VPWR VPWR _6632_/Y sky130_fd_sc_hd__inv_2
X_3844_ _3741_/X _3841_/X _3843_/X _3923_/A1 VGND VGND VPWR VPWR _3845_/B sky130_fd_sc_hd__a22o_2
X_6563_ _6599_/A VGND VGND VPWR VPWR _6563_/Y sky130_fd_sc_hd__inv_2
X_3775_ _3714_/X _3772_/X _3774_/X _3733_/X VGND VGND VPWR VPWR _3775_/X sky130_fd_sc_hd__a22o_2
X_6494_ _6651_/A VGND VGND VPWR VPWR _6494_/Y sky130_fd_sc_hd__inv_2
XTAP_TAPCELL_ROW_115_1629 VGND VPWR sky130_fd_sc_hd__tapvpwrvgnd_1
XFILLER_105_228 VGND VGND VPWR VPWR sky130_fd_sc_hd__decap_3
XFILLER_87_613 VGND VGND VPWR VPWR sky130_fd_sc_hd__decap_3
X_7115_ _7374_/CLK _7115_/D _6395_/Y VGND VGND VPWR VPWR _7115_/Q sky130_fd_sc_hd__dfrtp_2
Xoutput487 _3735_/A VGND VGND VPWR VPWR alu_result_out[4] sky130_fd_sc_hd__clkdlybuf4s25_1
Xoutput476 _5655_/D VGND VGND VPWR VPWR alu_result_out[23] sky130_fd_sc_hd__clkdlybuf4s25_1
Xoutput465 _5023_/Y VGND VGND VPWR VPWR alu_result_out[13] sky130_fd_sc_hd__clkdlybuf4s25_1
XFILLER_99_462 VGND VGND VPWR VPWR sky130_fd_sc_hd__decap_3
XFILLER_101_423 VGND VGND VPWR VPWR sky130_fd_sc_hd__decap_3
XFILLER_59_337 VGND VGND VPWR VPWR sky130_fd_sc_hd__fill_2
Xoutput498 _3429_/A VGND VGND VPWR VPWR instruction_out[15] sky130_fd_sc_hd__clkdlybuf4s25_1
X_4327_ _4327_/A _4327_/B VGND VGND VPWR VPWR _4362_/C sky130_fd_sc_hd__nand2_2
XFILLER_47_27 VGND VGND VPWR VPWR sky130_fd_sc_hd__decap_3
XFILLER_86_156 VGND VGND VPWR VPWR sky130_fd_sc_hd__decap_3
XFILLER_87_679 VGND VGND VPWR VPWR sky130_fd_sc_hd__decap_3
X_7046_ _7403_/CLK _7046_/D _6326_/Y VGND VGND VPWR VPWR _7046_/Q sky130_fd_sc_hd__dfrtp_2
X_4258_ _4988_/A _4988_/B VGND VGND VPWR VPWR _5003_/A sky130_fd_sc_hd__or2_4
XFILLER_101_489 VGND VGND VPWR VPWR sky130_fd_sc_hd__decap_3
XFILLER_103_33 VGND VGND VPWR VPWR sky130_fd_sc_hd__decap_3
XFILLER_27_212 VGND VGND VPWR VPWR sky130_fd_sc_hd__decap_3
XFILLER_27_234 VGND VGND VPWR VPWR sky130_fd_sc_hd__decap_3
X_4189_ _7231_/Q _4349_/B1 _4459_/C1 _7167_/Q _4188_/X VGND VGND VPWR VPWR _4189_/X
+ sky130_fd_sc_hd__a221o_2
XFILLER_103_66 VGND VGND VPWR VPWR sky130_fd_sc_hd__decap_3
XFILLER_63_15 VGND VGND VPWR VPWR sky130_fd_sc_hd__decap_3
XFILLER_82_351 VGND VGND VPWR VPWR sky130_fd_sc_hd__decap_3
XFILLER_27_278 VGND VGND VPWR VPWR sky130_fd_sc_hd__fill_2
XFILLER_70_513 VGND VGND VPWR VPWR sky130_fd_sc_hd__decap_3
XFILLER_82_395 VGND VGND VPWR VPWR sky130_fd_sc_hd__decap_3
XFILLER_42_248 VGND VGND VPWR VPWR sky130_fd_sc_hd__decap_3
XFILLER_42_259 VGND VGND VPWR VPWR sky130_fd_sc_hd__decap_3
XFILLER_10_123 VGND VGND VPWR VPWR sky130_fd_sc_hd__decap_3
XFILLER_11_668 VGND VGND VPWR VPWR sky130_fd_sc_hd__decap_3
XFILLER_109_545 VGND VGND VPWR VPWR sky130_fd_sc_hd__decap_3
XFILLER_109_567 VGND VGND VPWR VPWR sky130_fd_sc_hd__decap_3
XFILLER_12_41 VGND VGND VPWR VPWR sky130_fd_sc_hd__decap_3
XFILLER_6_127 VGND VGND VPWR VPWR sky130_fd_sc_hd__decap_3
XFILLER_88_12 VGND VGND VPWR VPWR sky130_fd_sc_hd__fill_1
XFILLER_88_67 VGND VGND VPWR VPWR sky130_fd_sc_hd__decap_3
XFILLER_2_377 VGND VGND VPWR VPWR sky130_fd_sc_hd__decap_3
XFILLER_77_101 VGND VGND VPWR VPWR sky130_fd_sc_hd__decap_3
XFILLER_78_679 VGND VGND VPWR VPWR sky130_fd_sc_hd__decap_3
XFILLER_65_329 VGND VGND VPWR VPWR sky130_fd_sc_hd__decap_3
XFILLER_93_638 VGND VGND VPWR VPWR sky130_fd_sc_hd__decap_3
XFILLER_92_126 VGND VGND VPWR VPWR sky130_fd_sc_hd__decap_3
XFILLER_18_245 VGND VGND VPWR VPWR sky130_fd_sc_hd__decap_3
XFILLER_18_256 VGND VGND VPWR VPWR sky130_fd_sc_hd__fill_2
XFILLER_37_93 VGND VGND VPWR VPWR sky130_fd_sc_hd__decap_3
XFILLER_73_340 VGND VGND VPWR VPWR sky130_fd_sc_hd__fill_1
XPHY_EDGE_ROW_16_Right_16 VGND VGND VPWR VPWR sky130_fd_sc_hd__decap_3
XFILLER_46_587 VGND VGND VPWR VPWR sky130_fd_sc_hd__fill_1
XFILLER_61_557 VGND VGND VPWR VPWR sky130_fd_sc_hd__decap_3
XTAP_TAPCELL_ROW_16_446 VGND VPWR sky130_fd_sc_hd__tapvpwrvgnd_1
XFILLER_14_473 VGND VGND VPWR VPWR sky130_fd_sc_hd__decap_3
XTAP_TAPCELL_ROW_44_777 VGND VPWR sky130_fd_sc_hd__tapvpwrvgnd_1
XFILLER_41_270 VGND VGND VPWR VPWR sky130_fd_sc_hd__decap_3
XFILLER_41_281 VGND VGND VPWR VPWR sky130_fd_sc_hd__decap_3
X_3560_ _5118_/D _3560_/B VGND VGND VPWR VPWR _3560_/Y sky130_fd_sc_hd__nor2_2
XPHY_EDGE_ROW_25_Right_25 VGND VGND VPWR VPWR sky130_fd_sc_hd__decap_3
XFILLER_6_672 VGND VGND VPWR VPWR sky130_fd_sc_hd__decap_3
XFILLER_115_548 VGND VGND VPWR VPWR sky130_fd_sc_hd__decap_3
XFILLER_5_160 VGND VGND VPWR VPWR sky130_fd_sc_hd__decap_3
X_3491_ _7215_/Q _3377_/X _3366_/X _7151_/Q _3490_/X VGND VGND VPWR VPWR _3491_/X
+ sky130_fd_sc_hd__a221o_2
X_5161_ _5161_/A _5641_/A VGND VGND VPWR VPWR _5194_/B sky130_fd_sc_hd__or2_2
XFILLER_69_657 VGND VGND VPWR VPWR sky130_fd_sc_hd__decap_3
XFILLER_69_679 VGND VGND VPWR VPWR sky130_fd_sc_hd__decap_3
X_5092_ _5069_/B _5092_/B _5092_/C VGND VGND VPWR VPWR _5092_/X sky130_fd_sc_hd__and3b_2
X_4112_ _7332_/Q _3962_/S _4499_/S _7300_/Q VGND VGND VPWR VPWR _4112_/X sky130_fd_sc_hd__a22o_2
XFILLER_110_253 VGND VGND VPWR VPWR sky130_fd_sc_hd__decap_3
XFILLER_56_307 VGND VGND VPWR VPWR sky130_fd_sc_hd__fill_1
XFILLER_56_318 VGND VGND VPWR VPWR sky130_fd_sc_hd__decap_3
XFILLER_68_156 VGND VGND VPWR VPWR sky130_fd_sc_hd__fill_1
XFILLER_68_189 VGND VGND VPWR VPWR sky130_fd_sc_hd__decap_3
XFILLER_83_104 VGND VGND VPWR VPWR sky130_fd_sc_hd__decap_3
XFILLER_84_616 VGND VGND VPWR VPWR sky130_fd_sc_hd__decap_3
X_4043_ _7309_/Q _4478_/S _4430_/B1 _7181_/Q _4042_/X VGND VGND VPWR VPWR _4043_/X
+ sky130_fd_sc_hd__a221o_2
XFILLER_49_381 VGND VGND VPWR VPWR sky130_fd_sc_hd__fill_2
XFILLER_83_137 VGND VGND VPWR VPWR sky130_fd_sc_hd__decap_3
XPHY_EDGE_ROW_34_Right_34 VGND VGND VPWR VPWR sky130_fd_sc_hd__decap_3
XFILLER_64_340 VGND VGND VPWR VPWR sky130_fd_sc_hd__decap_3
XFILLER_92_660 VGND VGND VPWR VPWR sky130_fd_sc_hd__decap_3
XFILLER_52_513 VGND VGND VPWR VPWR sky130_fd_sc_hd__decap_3
XFILLER_64_384 VGND VGND VPWR VPWR sky130_fd_sc_hd__decap_3
XTAP_TAPCELL_ROW_65_1027 VGND VPWR sky130_fd_sc_hd__tapvpwrvgnd_1
XFILLER_24_237 VGND VGND VPWR VPWR sky130_fd_sc_hd__decap_3
XFILLER_24_259 VGND VGND VPWR VPWR sky130_fd_sc_hd__decap_3
X_4945_ _4836_/S _6995_/D _5657_/C _4944_/X VGND VGND VPWR VPWR _4945_/X sky130_fd_sc_hd__o22a_2
XFILLER_20_421 VGND VGND VPWR VPWR sky130_fd_sc_hd__fill_1
X_6615_ _6619_/A VGND VGND VPWR VPWR _6615_/Y sky130_fd_sc_hd__inv_2
X_3827_ _6700_/Q _5660_/B _3869_/B1 _6878_/Q VGND VGND VPWR VPWR _3827_/X sky130_fd_sc_hd__a22o_2
XPHY_EDGE_ROW_43_Right_43 VGND VGND VPWR VPWR sky130_fd_sc_hd__decap_3
X_6546_ _6578_/A VGND VGND VPWR VPWR _6546_/Y sky130_fd_sc_hd__inv_2
XFILLER_3_108 VGND VGND VPWR VPWR sky130_fd_sc_hd__decap_3
XFILLER_106_548 VGND VGND VPWR VPWR sky130_fd_sc_hd__decap_3
XFILLER_3_119 VGND VGND VPWR VPWR sky130_fd_sc_hd__decap_3
X_6477_ _6608_/A VGND VGND VPWR VPWR _6477_/Y sky130_fd_sc_hd__inv_2
XTAP_TAPCELL_ROW_76_1167 VGND VPWR sky130_fd_sc_hd__tapvpwrvgnd_1
XFILLER_114_581 VGND VGND VPWR VPWR sky130_fd_sc_hd__decap_3
XFILLER_87_421 VGND VGND VPWR VPWR sky130_fd_sc_hd__decap_3
XFILLER_99_281 VGND VGND VPWR VPWR sky130_fd_sc_hd__decap_3
XFILLER_101_220 VGND VGND VPWR VPWR sky130_fd_sc_hd__decap_3
XFILLER_114_592 VGND VGND VPWR VPWR sky130_fd_sc_hd__decap_3
XFILLER_59_123 VGND VGND VPWR VPWR sky130_fd_sc_hd__decap_3
XFILLER_101_264 VGND VGND VPWR VPWR sky130_fd_sc_hd__decap_3
XFILLER_114_21 VGND VGND VPWR VPWR sky130_fd_sc_hd__decap_3
XFILLER_114_32 VGND VGND VPWR VPWR sky130_fd_sc_hd__decap_3
XFILLER_59_167 VGND VGND VPWR VPWR sky130_fd_sc_hd__fill_1
XFILLER_59_178 VGND VGND VPWR VPWR sky130_fd_sc_hd__decap_3
X_7029_ _7386_/CLK _7029_/D _6309_/Y VGND VGND VPWR VPWR _7029_/Q sky130_fd_sc_hd__dfrtp_2
XPHY_EDGE_ROW_52_Right_52 VGND VGND VPWR VPWR sky130_fd_sc_hd__decap_3
XFILLER_114_65 VGND VGND VPWR VPWR sky130_fd_sc_hd__decap_3
XFILLER_74_14 VGND VGND VPWR VPWR sky130_fd_sc_hd__decap_3
XFILLER_28_554 VGND VGND VPWR VPWR sky130_fd_sc_hd__decap_3
XFILLER_55_340 VGND VGND VPWR VPWR sky130_fd_sc_hd__decap_3
XFILLER_74_47 VGND VGND VPWR VPWR sky130_fd_sc_hd__decap_3
XFILLER_90_608 VGND VGND VPWR VPWR sky130_fd_sc_hd__fill_2
XFILLER_55_373 VGND VGND VPWR VPWR sky130_fd_sc_hd__decap_3
XTAP_TAPCELL_ROW_87_1296 VGND VPWR sky130_fd_sc_hd__tapvpwrvgnd_1
XFILLER_15_237 VGND VGND VPWR VPWR sky130_fd_sc_hd__decap_3
XFILLER_30_218 VGND VGND VPWR VPWR sky130_fd_sc_hd__decap_3
XFILLER_43_579 VGND VGND VPWR VPWR sky130_fd_sc_hd__fill_1
XFILLER_70_365 VGND VGND VPWR VPWR sky130_fd_sc_hd__decap_3
XFILLER_90_35 VGND VGND VPWR VPWR sky130_fd_sc_hd__fill_2
XTAP_TAPCELL_ROW_13_405 VGND VPWR sky130_fd_sc_hd__tapvpwrvgnd_1
XFILLER_23_281 VGND VGND VPWR VPWR sky130_fd_sc_hd__decap_3
XFILLER_90_79 VGND VGND VPWR VPWR sky130_fd_sc_hd__decap_3
XTAP_TAPCELL_ROW_41_747 VGND VPWR sky130_fd_sc_hd__tapvpwrvgnd_1
XPHY_EDGE_ROW_61_Right_61 VGND VGND VPWR VPWR sky130_fd_sc_hd__decap_3
XFILLER_11_465 VGND VGND VPWR VPWR sky130_fd_sc_hd__fill_2
XFILLER_99_33 VGND VGND VPWR VPWR sky130_fd_sc_hd__decap_3
XFILLER_99_66 VGND VGND VPWR VPWR sky130_fd_sc_hd__decap_3
XFILLER_2_130 VGND VGND VPWR VPWR sky130_fd_sc_hd__decap_3
XFILLER_3_653 VGND VGND VPWR VPWR sky130_fd_sc_hd__decap_3
XFILLER_99_99 VGND VGND VPWR VPWR sky130_fd_sc_hd__decap_3
XFILLER_105_570 VGND VGND VPWR VPWR sky130_fd_sc_hd__decap_3
XFILLER_2_141 VGND VGND VPWR VPWR sky130_fd_sc_hd__decap_3
XFILLER_78_421 VGND VGND VPWR VPWR sky130_fd_sc_hd__decap_3
XPHY_EDGE_ROW_70_Right_70 VGND VGND VPWR VPWR sky130_fd_sc_hd__decap_3
XFILLER_78_454 VGND VGND VPWR VPWR sky130_fd_sc_hd__decap_3
XFILLER_38_307 VGND VGND VPWR VPWR sky130_fd_sc_hd__fill_1
XFILLER_65_104 VGND VGND VPWR VPWR sky130_fd_sc_hd__decap_3
XFILLER_0_11 VGND VGND VPWR VPWR sky130_fd_sc_hd__decap_3
XFILLER_48_81 VGND VGND VPWR VPWR sky130_fd_sc_hd__decap_3
XFILLER_48_92 VGND VGND VPWR VPWR sky130_fd_sc_hd__decap_3
XFILLER_78_498 VGND VGND VPWR VPWR sky130_fd_sc_hd__decap_3
Xsingle_cycle_cpu_577 VGND VGND VPWR VPWR single_cycle_cpu_577/HI instruction_out[29]
+ sky130_fd_sc_hd__conb_1
XTAP_TAPCELL_ROW_49_836 VGND VPWR sky130_fd_sc_hd__tapvpwrvgnd_1
XFILLER_0_44 VGND VGND VPWR VPWR sky130_fd_sc_hd__decap_3
XFILLER_65_159 VGND VGND VPWR VPWR sky130_fd_sc_hd__decap_3
XFILLER_81_608 VGND VGND VPWR VPWR sky130_fd_sc_hd__decap_3
XFILLER_93_479 VGND VGND VPWR VPWR sky130_fd_sc_hd__decap_3
XFILLER_0_77 VGND VGND VPWR VPWR sky130_fd_sc_hd__decap_3
XFILLER_19_587 VGND VGND VPWR VPWR sky130_fd_sc_hd__decap_3
XFILLER_61_332 VGND VGND VPWR VPWR sky130_fd_sc_hd__decap_3
XFILLER_61_343 VGND VGND VPWR VPWR sky130_fd_sc_hd__decap_3
XFILLER_64_80 VGND VGND VPWR VPWR sky130_fd_sc_hd__decap_3
XFILLER_73_192 VGND VGND VPWR VPWR sky130_fd_sc_hd__decap_3
XPHY_EDGE_ROW_14_Left_131 VGND VGND VPWR VPWR sky130_fd_sc_hd__decap_3
XFILLER_61_387 VGND VGND VPWR VPWR sky130_fd_sc_hd__decap_3
X_4730_ _7007_/Q _4738_/A VGND VGND VPWR VPWR _4731_/A sky130_fd_sc_hd__or2_2
XFILLER_9_42 VGND VGND VPWR VPWR sky130_fd_sc_hd__decap_3
XFILLER_9_75 VGND VGND VPWR VPWR sky130_fd_sc_hd__decap_3
X_7380_ clkload4/A _7380_/D _6660_/Y VGND VGND VPWR VPWR _7380_/Q sky130_fd_sc_hd__dfrtp_2
X_6400_ _6637_/A VGND VGND VPWR VPWR _6400_/Y sky130_fd_sc_hd__inv_2
X_3612_ _3536_/B _4614_/B _3610_/Y _3611_/Y VGND VGND VPWR VPWR _3612_/X sky130_fd_sc_hd__a211o_2
Xhold904 _7057_/Q VGND VGND VPWR VPWR _7057_/D sky130_fd_sc_hd__dlygate4sd3_1
X_6331_ _6682_/A VGND VGND VPWR VPWR _6331_/Y sky130_fd_sc_hd__inv_2
Xhold915 _6708_/Q VGND VGND VPWR VPWR hold915/X sky130_fd_sc_hd__dlygate4sd3_1
Xhold926 _7030_/Q VGND VGND VPWR VPWR _5595_/A sky130_fd_sc_hd__dlygate4sd3_1
Xhold937 _7016_/Q VGND VGND VPWR VPWR _5624_/A sky130_fd_sc_hd__dlygate4sd3_1
X_3543_ _3540_/X _3541_/X _5144_/A VGND VGND VPWR VPWR _3630_/B sky130_fd_sc_hd__o21ai_2
Xhold959 _7029_/Q VGND VGND VPWR VPWR hold959/X sky130_fd_sc_hd__dlygate4sd3_1
Xhold948 _6713_/Q VGND VGND VPWR VPWR hold948/X sky130_fd_sc_hd__dlygate4sd3_1
X_6262_ _6642_/A VGND VGND VPWR VPWR _6262_/Y sky130_fd_sc_hd__inv_2
X_3474_ _7280_/Q _4534_/S _4339_/B1 _7152_/Q _3473_/X VGND VGND VPWR VPWR _3474_/X
+ sky130_fd_sc_hd__a221o_2
XPHY_EDGE_ROW_23_Left_140 VGND VGND VPWR VPWR sky130_fd_sc_hd__decap_3
XFILLER_88_218 VGND VGND VPWR VPWR sky130_fd_sc_hd__decap_3
X_5213_ _7222_/Q _5217_/B VGND VGND VPWR VPWR _7222_/D sky130_fd_sc_hd__and2_2
XFILLER_69_432 VGND VGND VPWR VPWR sky130_fd_sc_hd__decap_3
X_5144_ _5144_/A _5144_/B VGND VGND VPWR VPWR _5145_/A sky130_fd_sc_hd__nand2_2
XFILLER_28_18 VGND VGND VPWR VPWR sky130_fd_sc_hd__fill_2
XFILLER_28_29 VGND VGND VPWR VPWR sky130_fd_sc_hd__fill_2
XFILLER_57_605 VGND VGND VPWR VPWR sky130_fd_sc_hd__decap_3
XFILLER_56_137 VGND VGND VPWR VPWR sky130_fd_sc_hd__decap_3
XFILLER_57_638 VGND VGND VPWR VPWR sky130_fd_sc_hd__decap_3
XFILLER_84_424 VGND VGND VPWR VPWR sky130_fd_sc_hd__decap_3
XFILLER_96_284 VGND VGND VPWR VPWR sky130_fd_sc_hd__decap_3
X_5075_ _5075_/A _5075_/B _5075_/C VGND VGND VPWR VPWR _5658_/A sky130_fd_sc_hd__or3_2
XFILLER_72_619 VGND VGND VPWR VPWR sky130_fd_sc_hd__fill_1
XFILLER_84_457 VGND VGND VPWR VPWR sky130_fd_sc_hd__decap_3
XFILLER_65_671 VGND VGND VPWR VPWR sky130_fd_sc_hd__fill_1
XFILLER_65_682 VGND VGND VPWR VPWR sky130_fd_sc_hd__decap_3
XFILLER_71_107 VGND VGND VPWR VPWR sky130_fd_sc_hd__fill_2
XFILLER_71_129 VGND VGND VPWR VPWR sky130_fd_sc_hd__decap_3
XFILLER_25_557 VGND VGND VPWR VPWR sky130_fd_sc_hd__decap_3
XFILLER_52_321 VGND VGND VPWR VPWR sky130_fd_sc_hd__decap_3
XFILLER_100_12 VGND VGND VPWR VPWR sky130_fd_sc_hd__decap_3
XFILLER_12_218 VGND VGND VPWR VPWR sky130_fd_sc_hd__decap_3
XFILLER_40_505 VGND VGND VPWR VPWR sky130_fd_sc_hd__decap_3
XFILLER_52_354 VGND VGND VPWR VPWR sky130_fd_sc_hd__fill_1
XFILLER_52_365 VGND VGND VPWR VPWR sky130_fd_sc_hd__decap_3
X_4928_ _6996_/Q _4928_/B _4943_/A VGND VGND VPWR VPWR _4928_/Y sky130_fd_sc_hd__nor3_2
XFILLER_100_56 VGND VGND VPWR VPWR sky130_fd_sc_hd__decap_3
XFILLER_60_38 VGND VGND VPWR VPWR sky130_fd_sc_hd__fill_2
X_4859_ _7000_/Q _4870_/A VGND VGND VPWR VPWR _4859_/Y sky130_fd_sc_hd__nor2_2
XFILLER_109_21 VGND VGND VPWR VPWR sky130_fd_sc_hd__decap_3
XFILLER_114_6 VGND VGND VPWR VPWR sky130_fd_sc_hd__decap_3
Xclkbuf_3_0__f_clk clkbuf_0_clk/X VGND VGND VPWR VPWR clkbuf_3_0__f_clk/X sky130_fd_sc_hd__clkbuf_16
XFILLER_106_312 VGND VGND VPWR VPWR sky130_fd_sc_hd__decap_3
XFILLER_109_54 VGND VGND VPWR VPWR sky130_fd_sc_hd__fill_2
XFILLER_4_417 VGND VGND VPWR VPWR sky130_fd_sc_hd__decap_3
X_6529_ _6562_/A VGND VGND VPWR VPWR _6529_/Y sky130_fd_sc_hd__inv_2
XFILLER_109_87 VGND VGND VPWR VPWR sky130_fd_sc_hd__decap_3
XFILLER_69_36 VGND VGND VPWR VPWR sky130_fd_sc_hd__decap_3
XFILLER_69_69 VGND VGND VPWR VPWR sky130_fd_sc_hd__decap_3
XFILLER_0_623 VGND VGND VPWR VPWR sky130_fd_sc_hd__decap_3
XFILLER_0_645 VGND VGND VPWR VPWR sky130_fd_sc_hd__decap_3
XFILLER_102_551 VGND VGND VPWR VPWR sky130_fd_sc_hd__decap_3
XFILLER_48_627 VGND VGND VPWR VPWR sky130_fd_sc_hd__decap_3
XFILLER_75_435 VGND VGND VPWR VPWR sky130_fd_sc_hd__decap_3
XFILLER_87_273 VGND VGND VPWR VPWR sky130_fd_sc_hd__decap_3
XTAP_TAPCELL_ROW_89_1325 VGND VPWR sky130_fd_sc_hd__tapvpwrvgnd_1
XTAP_TAPCELL_ROW_89_1314 VGND VPWR sky130_fd_sc_hd__tapvpwrvgnd_1
XFILLER_18_62 VGND VGND VPWR VPWR sky130_fd_sc_hd__decap_3
XFILLER_56_660 VGND VGND VPWR VPWR sky130_fd_sc_hd__decap_3
XTAP_TAPCELL_ROW_46_806 VGND VPWR sky130_fd_sc_hd__tapvpwrvgnd_1
XFILLER_62_129 VGND VGND VPWR VPWR sky130_fd_sc_hd__decap_3
XFILLER_55_192 VGND VGND VPWR VPWR sky130_fd_sc_hd__decap_3
XFILLER_71_641 VGND VGND VPWR VPWR sky130_fd_sc_hd__decap_3
XFILLER_31_505 VGND VGND VPWR VPWR sky130_fd_sc_hd__decap_3
XFILLER_71_685 VGND VGND VPWR VPWR sky130_fd_sc_hd__decap_3
XTAP_TAPCELL_ROW_26_563 VGND VPWR sky130_fd_sc_hd__tapvpwrvgnd_1
XFILLER_31_538 VGND VGND VPWR VPWR sky130_fd_sc_hd__fill_1
XFILLER_70_184 VGND VGND VPWR VPWR sky130_fd_sc_hd__decap_3
XTAP_TAPCELL_ROW_54_894 VGND VPWR sky130_fd_sc_hd__tapvpwrvgnd_1
XFILLER_11_240 VGND VGND VPWR VPWR sky130_fd_sc_hd__decap_3
XFILLER_79_9 VGND VGND VPWR VPWR sky130_fd_sc_hd__fill_1
XFILLER_109_150 VGND VGND VPWR VPWR sky130_fd_sc_hd__decap_3
XFILLER_116_109 VGND VGND VPWR VPWR sky130_fd_sc_hd__decap_3
XFILLER_109_172 VGND VGND VPWR VPWR sky130_fd_sc_hd__decap_3
XFILLER_50_71 VGND VGND VPWR VPWR sky130_fd_sc_hd__fill_2
XFILLER_50_82 VGND VGND VPWR VPWR sky130_fd_sc_hd__fill_2
XFILLER_98_549 VGND VGND VPWR VPWR sky130_fd_sc_hd__decap_3
XFILLER_66_402 VGND VGND VPWR VPWR sky130_fd_sc_hd__fill_1
XFILLER_93_210 VGND VGND VPWR VPWR sky130_fd_sc_hd__decap_3
XFILLER_38_159 VGND VGND VPWR VPWR sky130_fd_sc_hd__decap_3
XFILLER_54_619 VGND VGND VPWR VPWR sky130_fd_sc_hd__decap_3
XFILLER_93_243 VGND VGND VPWR VPWR sky130_fd_sc_hd__decap_3
XFILLER_93_254 VGND VGND VPWR VPWR sky130_fd_sc_hd__decap_3
XFILLER_47_671 VGND VGND VPWR VPWR sky130_fd_sc_hd__fill_1
XFILLER_47_682 VGND VGND VPWR VPWR sky130_fd_sc_hd__decap_3
XFILLER_75_90 VGND VGND VPWR VPWR sky130_fd_sc_hd__decap_3
XTAP_TAPCELL_ROW_109_1561 VGND VPWR sky130_fd_sc_hd__tapvpwrvgnd_1
XFILLER_46_192 VGND VGND VPWR VPWR sky130_fd_sc_hd__decap_3
XFILLER_62_641 VGND VGND VPWR VPWR sky130_fd_sc_hd__decap_3
XFILLER_81_449 VGND VGND VPWR VPWR sky130_fd_sc_hd__decap_3
X_6880_ _7392_/CLK _6880_/D VGND VGND VPWR VPWR _6880_/Q sky130_fd_sc_hd__dfxtp_2
XFILLER_34_376 VGND VGND VPWR VPWR sky130_fd_sc_hd__decap_3
XFILLER_61_162 VGND VGND VPWR VPWR sky130_fd_sc_hd__decap_3
XFILLER_62_663 VGND VGND VPWR VPWR sky130_fd_sc_hd__decap_3
XFILLER_15_590 VGND VGND VPWR VPWR sky130_fd_sc_hd__decap_3
XFILLER_34_398 VGND VGND VPWR VPWR sky130_fd_sc_hd__decap_3
XFILLER_61_184 VGND VGND VPWR VPWR sky130_fd_sc_hd__decap_3
X_4713_ _7008_/Q _4731_/B VGND VGND VPWR VPWR _7008_/D sky130_fd_sc_hd__xnor2_2
X_5693_ _7352_/Q hold907/X _5708_/S VGND VGND VPWR VPWR _6696_/D sky130_fd_sc_hd__mux2_2
XFILLER_107_109 VGND VGND VPWR VPWR sky130_fd_sc_hd__decap_3
X_4644_ _4111_/B _4643_/Y _4633_/A _4109_/X VGND VGND VPWR VPWR _4644_/X sky130_fd_sc_hd__a211o_2
X_7363_ _7363_/CLK _7363_/D _6643_/Y VGND VGND VPWR VPWR _7363_/Q sky130_fd_sc_hd__dfrtp_2
Xhold701 _6823_/Q VGND VGND VPWR VPWR _6823_/D sky130_fd_sc_hd__dlygate4sd3_1
Xhold712 _6892_/Q VGND VGND VPWR VPWR _6892_/D sky130_fd_sc_hd__dlygate4sd3_1
X_4575_ _4575_/A _4595_/B VGND VGND VPWR VPWR _7293_/D sky130_fd_sc_hd__and2_2
XFILLER_115_131 VGND VGND VPWR VPWR sky130_fd_sc_hd__decap_3
XFILLER_116_654 VGND VGND VPWR VPWR sky130_fd_sc_hd__decap_3
XFILLER_89_505 VGND VGND VPWR VPWR sky130_fd_sc_hd__decap_3
X_7294_ _7358_/CLK _7294_/D _6574_/Y VGND VGND VPWR VPWR _7294_/Q sky130_fd_sc_hd__dfrtp_2
Xhold723 _6762_/Q VGND VGND VPWR VPWR _6762_/D sky130_fd_sc_hd__dlygate4sd3_1
Xhold734 _6732_/Q VGND VGND VPWR VPWR _6732_/D sky130_fd_sc_hd__dlygate4sd3_1
Xhold745 _6905_/Q VGND VGND VPWR VPWR _6905_/D sky130_fd_sc_hd__dlygate4sd3_1
X_6314_ _6634_/A VGND VGND VPWR VPWR _6314_/Y sky130_fd_sc_hd__inv_2
X_3526_ _4938_/A _3526_/B VGND VGND VPWR VPWR _5057_/A sky130_fd_sc_hd__nand2_2
XFILLER_103_304 VGND VGND VPWR VPWR sky130_fd_sc_hd__decap_3
XFILLER_115_164 VGND VGND VPWR VPWR sky130_fd_sc_hd__decap_3
XFILLER_115_175 VGND VGND VPWR VPWR sky130_fd_sc_hd__decap_3
XFILLER_116_676 VGND VGND VPWR VPWR sky130_fd_sc_hd__decap_3
Xhold756 _6978_/Q VGND VGND VPWR VPWR _6978_/D sky130_fd_sc_hd__dlygate4sd3_1
Xhold767 _6962_/Q VGND VGND VPWR VPWR _6962_/D sky130_fd_sc_hd__dlygate4sd3_1
Xhold778 _6899_/Q VGND VGND VPWR VPWR _6899_/D sky130_fd_sc_hd__dlygate4sd3_1
XTAP_TAPCELL_ROW_73_1126 VGND VPWR sky130_fd_sc_hd__tapvpwrvgnd_1
Xhold789 _6957_/Q VGND VGND VPWR VPWR _6957_/D sky130_fd_sc_hd__dlygate4sd3_1
X_3457_ _4394_/A _3449_/C _3424_/S _3456_/X VGND VGND VPWR VPWR _3506_/B sky130_fd_sc_hd__a22o_2
XFILLER_69_240 VGND VGND VPWR VPWR sky130_fd_sc_hd__decap_3
X_3388_ _3394_/A _3429_/B VGND VGND VPWR VPWR _3388_/Y sky130_fd_sc_hd__nor2_2
XFILLER_111_370 VGND VGND VPWR VPWR sky130_fd_sc_hd__decap_3
XFILLER_29_104 VGND VGND VPWR VPWR sky130_fd_sc_hd__decap_3
XFILLER_57_413 VGND VGND VPWR VPWR sky130_fd_sc_hd__fill_1
XFILLER_84_221 VGND VGND VPWR VPWR sky130_fd_sc_hd__decap_3
X_5058_ _5114_/A _4330_/B _5056_/X _5057_/Y VGND VGND VPWR VPWR _5662_/B sky130_fd_sc_hd__a211o_2
XPHY_EDGE_ROW_2_Right_2 VGND VGND VPWR VPWR sky130_fd_sc_hd__decap_3
XFILLER_38_671 VGND VGND VPWR VPWR sky130_fd_sc_hd__decap_3
XFILLER_44_118 VGND VGND VPWR VPWR sky130_fd_sc_hd__fill_1
XFILLER_55_27 VGND VGND VPWR VPWR sky130_fd_sc_hd__decap_3
XFILLER_72_416 VGND VGND VPWR VPWR sky130_fd_sc_hd__decap_3
XFILLER_72_427 VGND VGND VPWR VPWR sky130_fd_sc_hd__decap_3
XFILLER_111_22 VGND VGND VPWR VPWR sky130_fd_sc_hd__decap_3
XFILLER_37_181 VGND VGND VPWR VPWR sky130_fd_sc_hd__decap_3
XFILLER_53_641 VGND VGND VPWR VPWR sky130_fd_sc_hd__decap_3
XFILLER_53_652 VGND VGND VPWR VPWR sky130_fd_sc_hd__decap_3
XFILLER_111_55 VGND VGND VPWR VPWR sky130_fd_sc_hd__fill_1
XFILLER_13_505 VGND VGND VPWR VPWR sky130_fd_sc_hd__fill_1
XFILLER_52_162 VGND VGND VPWR VPWR sky130_fd_sc_hd__decap_3
XTAP_TAPCELL_ROW_84_1255 VGND VPWR sky130_fd_sc_hd__tapvpwrvgnd_1
XFILLER_111_66 VGND VGND VPWR VPWR sky130_fd_sc_hd__decap_3
XFILLER_40_324 VGND VGND VPWR VPWR sky130_fd_sc_hd__fill_2
XFILLER_40_335 VGND VGND VPWR VPWR sky130_fd_sc_hd__decap_3
XFILLER_52_195 VGND VGND VPWR VPWR sky130_fd_sc_hd__fill_1
XTAP_TAPCELL_ROW_23_522 VGND VPWR sky130_fd_sc_hd__tapvpwrvgnd_1
XFILLER_111_99 VGND VGND VPWR VPWR sky130_fd_sc_hd__decap_3
XFILLER_40_368 VGND VGND VPWR VPWR sky130_fd_sc_hd__decap_3
XTAP_TAPCELL_ROW_51_864 VGND VPWR sky130_fd_sc_hd__tapvpwrvgnd_1
XTAP_TAPCELL_ROW_23_533 VGND VPWR sky130_fd_sc_hd__tapvpwrvgnd_1
XFILLER_107_610 VGND VGND VPWR VPWR sky130_fd_sc_hd__decap_3
XFILLER_4_203 VGND VGND VPWR VPWR sky130_fd_sc_hd__decap_3
XFILLER_107_665 VGND VGND VPWR VPWR sky130_fd_sc_hd__decap_3
XFILLER_20_41 VGND VGND VPWR VPWR sky130_fd_sc_hd__decap_3
XFILLER_107_676 VGND VGND VPWR VPWR sky130_fd_sc_hd__decap_3
XFILLER_20_85 VGND VGND VPWR VPWR sky130_fd_sc_hd__fill_1
XTAP_TAPCELL_ROW_95_1395 VGND VPWR sky130_fd_sc_hd__tapvpwrvgnd_1
XFILLER_106_197 VGND VGND VPWR VPWR sky130_fd_sc_hd__decap_3
XFILLER_96_23 VGND VGND VPWR VPWR sky130_fd_sc_hd__decap_3
XFILLER_0_464 VGND VGND VPWR VPWR sky130_fd_sc_hd__decap_3
XFILLER_96_56 VGND VGND VPWR VPWR sky130_fd_sc_hd__decap_3
XFILLER_96_67 VGND VGND VPWR VPWR sky130_fd_sc_hd__decap_3
XFILLER_48_413 VGND VGND VPWR VPWR sky130_fd_sc_hd__decap_3
XFILLER_75_221 VGND VGND VPWR VPWR sky130_fd_sc_hd__decap_3
XFILLER_88_582 VGND VGND VPWR VPWR sky130_fd_sc_hd__decap_3
XFILLER_102_392 VGND VGND VPWR VPWR sky130_fd_sc_hd__decap_3
XFILLER_29_72 VGND VGND VPWR VPWR sky130_fd_sc_hd__fill_2
XTAP_TAPCELL_ROW_59_964 VGND VPWR sky130_fd_sc_hd__tapvpwrvgnd_1
XFILLER_63_405 VGND VGND VPWR VPWR sky130_fd_sc_hd__fill_1
XFILLER_75_287 VGND VGND VPWR VPWR sky130_fd_sc_hd__decap_3
XFILLER_16_321 VGND VGND VPWR VPWR sky130_fd_sc_hd__decap_3
XFILLER_28_192 VGND VGND VPWR VPWR sky130_fd_sc_hd__decap_3
XFILLER_44_630 VGND VGND VPWR VPWR sky130_fd_sc_hd__decap_3
Xplace405 _4528_/B VGND VGND VPWR VPWR _4530_/S sky130_fd_sc_hd__buf_2
Xplace416 _3376_/Y VGND VGND VPWR VPWR _5161_/A sky130_fd_sc_hd__buf_2
Xplace427 _4268_/A2 VGND VGND VPWR VPWR _3977_/S sky130_fd_sc_hd__buf_2
Xplace438 _5015_/A VGND VGND VPWR VPWR _4777_/A sky130_fd_sc_hd__buf_2
XTAP_TAPCELL_ROW_3_291 VGND VPWR sky130_fd_sc_hd__tapvpwrvgnd_1
XFILLER_16_354 VGND VGND VPWR VPWR sky130_fd_sc_hd__fill_1
XFILLER_16_365 VGND VGND VPWR VPWR sky130_fd_sc_hd__decap_3
XFILLER_44_663 VGND VGND VPWR VPWR sky130_fd_sc_hd__decap_3
Xplace449 _3318_/B VGND VGND VPWR VPWR _4331_/A2 sky130_fd_sc_hd__buf_2
XFILLER_31_335 VGND VGND VPWR VPWR sky130_fd_sc_hd__fill_1
XFILLER_43_195 VGND VGND VPWR VPWR sky130_fd_sc_hd__decap_3
XFILLER_31_346 VGND VGND VPWR VPWR sky130_fd_sc_hd__decap_3
XFILLER_61_81 VGND VGND VPWR VPWR sky130_fd_sc_hd__decap_3
XFILLER_77_6 VGND VGND VPWR VPWR sky130_fd_sc_hd__decap_3
XANTENNA_3 _3429_/A VGND VGND VPWR VPWR sky130_fd_sc_hd__diode_2
XFILLER_6_21 VGND VGND VPWR VPWR sky130_fd_sc_hd__decap_3
XFILLER_6_32 VGND VGND VPWR VPWR sky130_fd_sc_hd__decap_3
XFILLER_6_65 VGND VGND VPWR VPWR sky130_fd_sc_hd__decap_3
X_4360_ _5072_/B _5071_/B VGND VGND VPWR VPWR _5073_/A sky130_fd_sc_hd__nand2_2
X_3311_ _5118_/C _4696_/B _3340_/B VGND VGND VPWR VPWR _5671_/A sky130_fd_sc_hd__o21ai_2
XFILLER_112_112 VGND VGND VPWR VPWR sky130_fd_sc_hd__decap_3
XFILLER_113_635 VGND VGND VPWR VPWR sky130_fd_sc_hd__decap_3
X_4291_ _4612_/A _4612_/B VGND VGND VPWR VPWR _4292_/C sky130_fd_sc_hd__xnor2_2
XFILLER_98_357 VGND VGND VPWR VPWR sky130_fd_sc_hd__decap_3
XFILLER_100_307 VGND VGND VPWR VPWR sky130_fd_sc_hd__fill_1
XFILLER_112_156 VGND VGND VPWR VPWR sky130_fd_sc_hd__decap_3
XFILLER_113_668 VGND VGND VPWR VPWR sky130_fd_sc_hd__decap_3
XFILLER_113_679 VGND VGND VPWR VPWR sky130_fd_sc_hd__decap_3
XFILLER_98_368 VGND VGND VPWR VPWR sky130_fd_sc_hd__decap_3
XFILLER_112_189 VGND VGND VPWR VPWR sky130_fd_sc_hd__decap_3
XFILLER_66_232 VGND VGND VPWR VPWR sky130_fd_sc_hd__decap_3
XFILLER_66_243 VGND VGND VPWR VPWR sky130_fd_sc_hd__decap_3
XFILLER_94_530 VGND VGND VPWR VPWR sky130_fd_sc_hd__fill_2
XFILLER_94_563 VGND VGND VPWR VPWR sky130_fd_sc_hd__decap_3
XFILLER_26_118 VGND VGND VPWR VPWR sky130_fd_sc_hd__decap_3
XFILLER_81_213 VGND VGND VPWR VPWR sky130_fd_sc_hd__fill_2
XFILLER_19_181 VGND VGND VPWR VPWR sky130_fd_sc_hd__decap_3
X_6932_ _7230_/CLK _6932_/D VGND VGND VPWR VPWR _6932_/Q sky130_fd_sc_hd__dfxtp_2
XFILLER_50_600 VGND VGND VPWR VPWR sky130_fd_sc_hd__decap_3
XFILLER_81_268 VGND VGND VPWR VPWR sky130_fd_sc_hd__decap_3
X_6863_ _6929_/CLK _6863_/D VGND VGND VPWR VPWR _6863_/Q sky130_fd_sc_hd__dfxtp_2
XFILLER_22_302 VGND VGND VPWR VPWR sky130_fd_sc_hd__decap_3
XFILLER_34_162 VGND VGND VPWR VPWR sky130_fd_sc_hd__decap_3
XFILLER_50_633 VGND VGND VPWR VPWR sky130_fd_sc_hd__decap_3
XFILLER_22_368 VGND VGND VPWR VPWR sky130_fd_sc_hd__decap_3
XFILLER_34_195 VGND VGND VPWR VPWR sky130_fd_sc_hd__fill_1
XFILLER_50_666 VGND VGND VPWR VPWR sky130_fd_sc_hd__decap_3
X_6794_ _6977_/CLK _6794_/D VGND VGND VPWR VPWR _6794_/Q sky130_fd_sc_hd__dfxtp_2
XFILLER_41_29 VGND VGND VPWR VPWR sky130_fd_sc_hd__decap_3
X_5676_ _7344_/Q hold914/X _5721_/S VGND VGND VPWR VPWR _6688_/D sky130_fd_sc_hd__mux2_2
XFILLER_108_418 VGND VGND VPWR VPWR sky130_fd_sc_hd__fill_2
X_4627_ _4627_/A VGND VGND VPWR VPWR _4627_/Y sky130_fd_sc_hd__inv_2
XFILLER_104_602 VGND VGND VPWR VPWR sky130_fd_sc_hd__decap_3
X_7346_ clkload4/A _7346_/D _6626_/Y VGND VGND VPWR VPWR _7346_/Q sky130_fd_sc_hd__dfrtp_2
XFILLER_103_101 VGND VGND VPWR VPWR sky130_fd_sc_hd__decap_3
XFILLER_103_123 VGND VGND VPWR VPWR sky130_fd_sc_hd__decap_3
XFILLER_104_657 VGND VGND VPWR VPWR sky130_fd_sc_hd__decap_3
XFILLER_116_495 VGND VGND VPWR VPWR sky130_fd_sc_hd__decap_3
XFILLER_89_324 VGND VGND VPWR VPWR sky130_fd_sc_hd__decap_3
X_7277_ _7372_/CLK _7277_/D _6557_/Y VGND VGND VPWR VPWR _7277_/Q sky130_fd_sc_hd__dfrtp_2
Xhold586 _6864_/Q VGND VGND VPWR VPWR _6864_/D sky130_fd_sc_hd__dlygate4sd3_1
Xhold597 _6724_/Q VGND VGND VPWR VPWR _6724_/D sky130_fd_sc_hd__dlygate4sd3_1
X_3509_ _5640_/B _3509_/B VGND VGND VPWR VPWR _3509_/Y sky130_fd_sc_hd__nor2_2
XFILLER_9_9 VGND VGND VPWR VPWR sky130_fd_sc_hd__decap_3
XFILLER_106_44 VGND VGND VPWR VPWR sky130_fd_sc_hd__decap_3
XFILLER_89_379 VGND VGND VPWR VPWR sky130_fd_sc_hd__decap_3
XFILLER_112_690 VGND VGND VPWR VPWR sky130_fd_sc_hd__fill_2
XFILLER_57_210 VGND VGND VPWR VPWR sky130_fd_sc_hd__fill_2
XFILLER_106_88 VGND VGND VPWR VPWR sky130_fd_sc_hd__decap_3
XFILLER_66_48 VGND VGND VPWR VPWR sky130_fd_sc_hd__decap_3
XFILLER_57_287 VGND VGND VPWR VPWR sky130_fd_sc_hd__decap_3
XFILLER_85_585 VGND VGND VPWR VPWR sky130_fd_sc_hd__decap_3
XTAP_TAPCELL_ROW_56_923 VGND VPWR sky130_fd_sc_hd__tapvpwrvgnd_1
XFILLER_17_129 VGND VGND VPWR VPWR sky130_fd_sc_hd__decap_3
XFILLER_26_641 VGND VGND VPWR VPWR sky130_fd_sc_hd__decap_3
XFILLER_45_438 VGND VGND VPWR VPWR sky130_fd_sc_hd__decap_3
XFILLER_72_235 VGND VGND VPWR VPWR sky130_fd_sc_hd__decap_3
Xclkbuf_leaf_37_clk clkbuf_3_6__f_clk/X VGND VGND VPWR VPWR _7386_/CLK sky130_fd_sc_hd__clkbuf_16
XFILLER_25_140 VGND VGND VPWR VPWR sky130_fd_sc_hd__decap_3
XFILLER_41_600 VGND VGND VPWR VPWR sky130_fd_sc_hd__decap_3
XFILLER_82_25 VGND VGND VPWR VPWR sky130_fd_sc_hd__decap_3
XFILLER_82_47 VGND VGND VPWR VPWR sky130_fd_sc_hd__decap_3
XTAP_TAPCELL_ROW_0_250 VGND VPWR sky130_fd_sc_hd__tapvpwrvgnd_1
XFILLER_15_30 VGND VGND VPWR VPWR sky130_fd_sc_hd__decap_3
XFILLER_25_162 VGND VGND VPWR VPWR sky130_fd_sc_hd__decap_3
XTAP_TAPCELL_ROW_36_680 VGND VPWR sky130_fd_sc_hd__tapvpwrvgnd_1
XFILLER_13_368 VGND VGND VPWR VPWR sky130_fd_sc_hd__decap_3
XFILLER_15_63 VGND VGND VPWR VPWR sky130_fd_sc_hd__decap_3
XFILLER_40_132 VGND VGND VPWR VPWR sky130_fd_sc_hd__decap_3
XFILLER_41_644 VGND VGND VPWR VPWR sky130_fd_sc_hd__decap_3
XFILLER_80_290 VGND VGND VPWR VPWR sky130_fd_sc_hd__decap_3
XFILLER_41_688 VGND VGND VPWR VPWR sky130_fd_sc_hd__decap_3
XFILLER_21_390 VGND VGND VPWR VPWR sky130_fd_sc_hd__fill_2
XTAP_TAPCELL_ROW_97_1413 VGND VPWR sky130_fd_sc_hd__tapvpwrvgnd_1
XFILLER_31_51 VGND VGND VPWR VPWR sky130_fd_sc_hd__decap_3
XFILLER_107_473 VGND VGND VPWR VPWR sky130_fd_sc_hd__decap_3
XFILLER_5_567 VGND VGND VPWR VPWR sky130_fd_sc_hd__fill_2
XFILLER_107_495 VGND VGND VPWR VPWR sky130_fd_sc_hd__fill_1
XFILLER_110_616 VGND VGND VPWR VPWR sky130_fd_sc_hd__decap_3
XFILLER_68_519 VGND VGND VPWR VPWR sky130_fd_sc_hd__decap_3
XFILLER_95_305 VGND VGND VPWR VPWR sky130_fd_sc_hd__decap_3
XTAP_TAPCELL_ROW_8_350 VGND VPWR sky130_fd_sc_hd__tapvpwrvgnd_1
XFILLER_95_327 VGND VGND VPWR VPWR sky130_fd_sc_hd__decap_3
XFILLER_48_243 VGND VGND VPWR VPWR sky130_fd_sc_hd__decap_3
XFILLER_76_530 VGND VGND VPWR VPWR sky130_fd_sc_hd__fill_2
XFILLER_88_390 VGND VGND VPWR VPWR sky130_fd_sc_hd__decap_3
XFILLER_95_349 VGND VGND VPWR VPWR sky130_fd_sc_hd__fill_2
XFILLER_48_265 VGND VGND VPWR VPWR sky130_fd_sc_hd__decap_3
XFILLER_76_563 VGND VGND VPWR VPWR sky130_fd_sc_hd__decap_3
XFILLER_36_438 VGND VGND VPWR VPWR sky130_fd_sc_hd__decap_3
XFILLER_56_92 VGND VGND VPWR VPWR sky130_fd_sc_hd__decap_3
XFILLER_63_246 VGND VGND VPWR VPWR sky130_fd_sc_hd__fill_2
XFILLER_91_533 VGND VGND VPWR VPWR sky130_fd_sc_hd__fill_1
Xclkbuf_leaf_28_clk clkbuf_3_2__f_clk/X VGND VGND VPWR VPWR _6911_/CLK sky130_fd_sc_hd__clkbuf_16
XTAP_TAPCELL_ROW_106_1520 VGND VPWR sky130_fd_sc_hd__tapvpwrvgnd_1
XFILLER_51_408 VGND VGND VPWR VPWR sky130_fd_sc_hd__decap_3
XFILLER_16_162 VGND VGND VPWR VPWR sky130_fd_sc_hd__decap_3
XFILLER_16_184 VGND VGND VPWR VPWR sky130_fd_sc_hd__decap_3
XFILLER_44_471 VGND VGND VPWR VPWR sky130_fd_sc_hd__decap_3
Xplace279 _3884_/A2 VGND VGND VPWR VPWR _3912_/A2 sky130_fd_sc_hd__buf_2
Xplace268 _3665_/X VGND VGND VPWR VPWR _3917_/B1 sky130_fd_sc_hd__buf_2
XFILLER_32_666 VGND VGND VPWR VPWR sky130_fd_sc_hd__decap_3
XFILLER_71_290 VGND VGND VPWR VPWR sky130_fd_sc_hd__decap_3
X_3860_ _3860_/A0 _3859_/X _5151_/A VGND VGND VPWR VPWR _7386_/D sky130_fd_sc_hd__mux2_2
X_3791_ _3775_/X _3790_/X _3896_/B1 VGND VGND VPWR VPWR _4961_/A sky130_fd_sc_hd__o21a_2
XFILLER_31_187 VGND VGND VPWR VPWR sky130_fd_sc_hd__decap_3
XFILLER_75_3 VGND VGND VPWR VPWR sky130_fd_sc_hd__decap_3
X_7200_ _7230_/CLK _7200_/D _6480_/Y VGND VGND VPWR VPWR _7200_/Q sky130_fd_sc_hd__dfrtp_2
X_4412_ _4788_/B _4412_/B VGND VGND VPWR VPWR _4413_/A sky130_fd_sc_hd__or2_2
X_5392_ _5392_/A0 _4945_/X _5396_/S VGND VGND VPWR VPWR _7137_/D sky130_fd_sc_hd__mux2_2
XFILLER_99_611 VGND VGND VPWR VPWR sky130_fd_sc_hd__fill_2
XFILLER_113_410 VGND VGND VPWR VPWR sky130_fd_sc_hd__decap_3
X_7131_ _7322_/CLK _7131_/D _6411_/Y VGND VGND VPWR VPWR _7131_/Q sky130_fd_sc_hd__dfrtp_2
X_4343_ _4365_/C _4365_/A _4365_/B VGND VGND VPWR VPWR _4343_/X sky130_fd_sc_hd__and3b_2
XPHY_EDGE_ROW_99_Right_99 VGND VGND VPWR VPWR sky130_fd_sc_hd__decap_3
XFILLER_113_443 VGND VGND VPWR VPWR sky130_fd_sc_hd__decap_3
XFILLER_59_508 VGND VGND VPWR VPWR sky130_fd_sc_hd__decap_3
X_7062_ clkload8/A _7062_/D _6342_/Y VGND VGND VPWR VPWR _7062_/Q sky130_fd_sc_hd__dfrtp_2
X_4274_ _4376_/A _4376_/B _4376_/C _4273_/D VGND VGND VPWR VPWR _4274_/Y sky130_fd_sc_hd__o31ai_2
XFILLER_99_688 VGND VGND VPWR VPWR sky130_fd_sc_hd__decap_3
XFILLER_98_165 VGND VGND VPWR VPWR sky130_fd_sc_hd__decap_3
XFILLER_98_132 VGND VGND VPWR VPWR sky130_fd_sc_hd__decap_3
XFILLER_100_115 VGND VGND VPWR VPWR sky130_fd_sc_hd__fill_1
XFILLER_113_476 VGND VGND VPWR VPWR sky130_fd_sc_hd__decap_3
XFILLER_39_221 VGND VGND VPWR VPWR sky130_fd_sc_hd__decap_3
XFILLER_39_243 VGND VGND VPWR VPWR sky130_fd_sc_hd__decap_3
XFILLER_67_541 VGND VGND VPWR VPWR sky130_fd_sc_hd__fill_2
XFILLER_27_405 VGND VGND VPWR VPWR sky130_fd_sc_hd__fill_1
XFILLER_36_18 VGND VGND VPWR VPWR sky130_fd_sc_hd__decap_3
XFILLER_39_276 VGND VGND VPWR VPWR sky130_fd_sc_hd__decap_3
XFILLER_27_449 VGND VGND VPWR VPWR sky130_fd_sc_hd__decap_3
XFILLER_82_533 VGND VGND VPWR VPWR sky130_fd_sc_hd__decap_3
XFILLER_94_382 VGND VGND VPWR VPWR sky130_fd_sc_hd__decap_3
Xclkbuf_leaf_19_clk clkbuf_3_6__f_clk/X VGND VGND VPWR VPWR _7406_/CLK sky130_fd_sc_hd__clkbuf_16
XPHY_EDGE_ROW_6_Left_123 VGND VGND VPWR VPWR sky130_fd_sc_hd__decap_3
XFILLER_54_246 VGND VGND VPWR VPWR sky130_fd_sc_hd__decap_3
XFILLER_54_268 VGND VGND VPWR VPWR sky130_fd_sc_hd__decap_3
XFILLER_82_566 VGND VGND VPWR VPWR sky130_fd_sc_hd__fill_2
X_6915_ _7387_/CLK _6915_/D VGND VGND VPWR VPWR _6915_/Q sky130_fd_sc_hd__dfxtp_2
XTAP_TAPCELL_ROW_68_1069 VGND VPWR sky130_fd_sc_hd__tapvpwrvgnd_1
XTAP_TAPCELL_ROW_81_1225 VGND VPWR sky130_fd_sc_hd__tapvpwrvgnd_1
X_6846_ _6929_/CLK _6846_/D VGND VGND VPWR VPWR _6846_/Q sky130_fd_sc_hd__dfxtp_2
X_6777_ _6965_/CLK _6777_/D VGND VGND VPWR VPWR _6777_/Q sky130_fd_sc_hd__dfxtp_2
XTAP_TAPCELL_ROW_61_981 VGND VPWR sky130_fd_sc_hd__tapvpwrvgnd_1
XTAP_TAPCELL_ROW_33_650 VGND VPWR sky130_fd_sc_hd__tapvpwrvgnd_1
XFILLER_22_187 VGND VGND VPWR VPWR sky130_fd_sc_hd__decap_3
X_3989_ _7346_/Q _4530_/A0 _3989_/S VGND VGND VPWR VPWR _7346_/D sky130_fd_sc_hd__mux2_2
XFILLER_6_309 VGND VGND VPWR VPWR sky130_fd_sc_hd__decap_3
XFILLER_108_259 VGND VGND VPWR VPWR sky130_fd_sc_hd__fill_1
X_5659_ _5659_/A _5659_/B VGND VGND VPWR VPWR _5660_/D sky130_fd_sc_hd__nor2_2
XTAP_TAPCELL_ROW_79_1198 VGND VPWR sky130_fd_sc_hd__tapvpwrvgnd_1
XFILLER_104_421 VGND VGND VPWR VPWR sky130_fd_sc_hd__decap_3
XFILLER_116_270 VGND VGND VPWR VPWR sky130_fd_sc_hd__decap_3
XFILLER_116_292 VGND VGND VPWR VPWR sky130_fd_sc_hd__decap_3
XFILLER_7_6 VGND VGND VPWR VPWR sky130_fd_sc_hd__decap_3
XFILLER_89_121 VGND VGND VPWR VPWR sky130_fd_sc_hd__decap_3
X_7329_ _7363_/CLK _7329_/D _6609_/Y VGND VGND VPWR VPWR _7329_/Q sky130_fd_sc_hd__dfrtp_2
XTAP_TAPCELL_ROW_92_1354 VGND VPWR sky130_fd_sc_hd__tapvpwrvgnd_1
XFILLER_77_36 VGND VGND VPWR VPWR sky130_fd_sc_hd__decap_3
XFILLER_89_143 VGND VGND VPWR VPWR sky130_fd_sc_hd__fill_2
XFILLER_77_69 VGND VGND VPWR VPWR sky130_fd_sc_hd__decap_3
XFILLER_89_165 VGND VGND VPWR VPWR sky130_fd_sc_hd__decap_3
XFILLER_100_660 VGND VGND VPWR VPWR sky130_fd_sc_hd__decap_3
XFILLER_85_360 VGND VGND VPWR VPWR sky130_fd_sc_hd__decap_3
XFILLER_93_24 VGND VGND VPWR VPWR sky130_fd_sc_hd__decap_3
Xhold1050 _7385_/Q VGND VGND VPWR VPWR _3864_/A0 sky130_fd_sc_hd__dlygate4sd3_1
XFILLER_18_427 VGND VGND VPWR VPWR sky130_fd_sc_hd__decap_3
XFILLER_85_393 VGND VGND VPWR VPWR sky130_fd_sc_hd__decap_3
XFILLER_93_57 VGND VGND VPWR VPWR sky130_fd_sc_hd__decap_3
Xhold1061 _7187_/Q VGND VGND VPWR VPWR _5284_/A0 sky130_fd_sc_hd__dlygate4sd3_1
Xhold1072 _7325_/Q VGND VGND VPWR VPWR _4509_/A1 sky130_fd_sc_hd__dlygate4sd3_1
Xhold1083 _7327_/Q VGND VGND VPWR VPWR _4505_/A0 sky130_fd_sc_hd__dlygate4sd3_1
Xhold1094 _7310_/Q VGND VGND VPWR VPWR _4540_/A sky130_fd_sc_hd__dlygate4sd3_1
XFILLER_45_246 VGND VGND VPWR VPWR sky130_fd_sc_hd__decap_3
XFILLER_93_79 VGND VGND VPWR VPWR sky130_fd_sc_hd__decap_3
XFILLER_26_73 VGND VGND VPWR VPWR sky130_fd_sc_hd__decap_3
XFILLER_14_633 VGND VGND VPWR VPWR sky130_fd_sc_hd__fill_1
XFILLER_41_441 VGND VGND VPWR VPWR sky130_fd_sc_hd__decap_3
XFILLER_13_165 VGND VGND VPWR VPWR sky130_fd_sc_hd__decap_3
XTAP_TAPCELL_ROW_101_1461 VGND VPWR sky130_fd_sc_hd__tapvpwrvgnd_1
XFILLER_9_136 VGND VGND VPWR VPWR sky130_fd_sc_hd__decap_3
XFILLER_42_83 VGND VGND VPWR VPWR sky130_fd_sc_hd__fill_1
XFILLER_9_169 VGND VGND VPWR VPWR sky130_fd_sc_hd__decap_3
XFILLER_5_320 VGND VGND VPWR VPWR sky130_fd_sc_hd__decap_3
XFILLER_61_9 VGND VGND VPWR VPWR sky130_fd_sc_hd__decap_3
XTAP_TAPCELL_ROW_11_388 VGND VPWR sky130_fd_sc_hd__tapvpwrvgnd_1
XFILLER_114_218 VGND VGND VPWR VPWR sky130_fd_sc_hd__decap_3
XFILLER_107_281 VGND VGND VPWR VPWR sky130_fd_sc_hd__decap_3
XFILLER_110_424 VGND VGND VPWR VPWR sky130_fd_sc_hd__fill_2
XFILLER_3_33 VGND VGND VPWR VPWR sky130_fd_sc_hd__decap_3
XFILLER_95_102 VGND VGND VPWR VPWR sky130_fd_sc_hd__decap_3
XFILLER_95_113 VGND VGND VPWR VPWR sky130_fd_sc_hd__decap_3
XFILLER_96_614 VGND VGND VPWR VPWR sky130_fd_sc_hd__fill_1
XFILLER_110_435 VGND VGND VPWR VPWR sky130_fd_sc_hd__decap_3
XFILLER_3_66 VGND VGND VPWR VPWR sky130_fd_sc_hd__decap_3
XFILLER_68_349 VGND VGND VPWR VPWR sky130_fd_sc_hd__decap_3
XTAP_TAPCELL_ROW_112_1590 VGND VPWR sky130_fd_sc_hd__tapvpwrvgnd_1
XPHY_EDGE_ROW_79_Left_196 VGND VGND VPWR VPWR sky130_fd_sc_hd__decap_3
XFILLER_110_468 VGND VGND VPWR VPWR sky130_fd_sc_hd__decap_3
XFILLER_3_99 VGND VGND VPWR VPWR sky130_fd_sc_hd__decap_3
XFILLER_67_91 VGND VGND VPWR VPWR sky130_fd_sc_hd__fill_2
XFILLER_49_596 VGND VGND VPWR VPWR sky130_fd_sc_hd__decap_3
XFILLER_91_330 VGND VGND VPWR VPWR sky130_fd_sc_hd__decap_3
XFILLER_24_408 VGND VGND VPWR VPWR sky130_fd_sc_hd__decap_3
XFILLER_91_374 VGND VGND VPWR VPWR sky130_fd_sc_hd__fill_1
XFILLER_91_396 VGND VGND VPWR VPWR sky130_fd_sc_hd__decap_3
X_4961_ _4961_/A _5662_/C _4961_/C VGND VGND VPWR VPWR _4961_/X sky130_fd_sc_hd__or3_4
XTAP_TAPCELL_ROW_19_477 VGND VPWR sky130_fd_sc_hd__tapvpwrvgnd_1
XFILLER_32_441 VGND VGND VPWR VPWR sky130_fd_sc_hd__fill_2
XFILLER_44_290 VGND VGND VPWR VPWR sky130_fd_sc_hd__decap_3
X_6700_ _6931_/CLK _6700_/D VGND VGND VPWR VPWR _6700_/Q sky130_fd_sc_hd__dfxtp_2
X_4892_ _4884_/X _4886_/X _4887_/Y _4891_/X VGND VGND VPWR VPWR _5656_/B sky130_fd_sc_hd__a31o_2
X_3912_ _6905_/Q _3912_/A2 _3912_/B1 _6897_/Q VGND VGND VPWR VPWR _3912_/X sky130_fd_sc_hd__a22o_2
XFILLER_20_625 VGND VGND VPWR VPWR sky130_fd_sc_hd__fill_1
X_6631_ _6635_/A VGND VGND VPWR VPWR _6631_/Y sky130_fd_sc_hd__inv_2
X_3843_ _6699_/Q _3656_/Y _3917_/B1 _6877_/Q _3842_/X VGND VGND VPWR VPWR _3843_/X
+ sky130_fd_sc_hd__a221o_2
X_6562_ _6562_/A VGND VGND VPWR VPWR _6562_/Y sky130_fd_sc_hd__inv_2
X_3774_ _6757_/Q _3889_/B1 _3912_/B1 _6769_/Q _3773_/X VGND VGND VPWR VPWR _3774_/X
+ sky130_fd_sc_hd__a221o_2
XFILLER_9_670 VGND VGND VPWR VPWR sky130_fd_sc_hd__fill_2
X_6493_ _6651_/A VGND VGND VPWR VPWR _6493_/Y sky130_fd_sc_hd__inv_2
Xclkbuf_leaf_8_clk clkload2/A VGND VGND VPWR VPWR _7368_/CLK sky130_fd_sc_hd__clkbuf_16
XFILLER_113_240 VGND VGND VPWR VPWR sky130_fd_sc_hd__decap_3
X_7114_ _7338_/CLK _7114_/D _6394_/Y VGND VGND VPWR VPWR _7114_/Q sky130_fd_sc_hd__dfrtp_2
Xoutput477 _5657_/A VGND VGND VPWR VPWR alu_result_out[24] sky130_fd_sc_hd__clkdlybuf4s25_1
Xoutput466 _5662_/A VGND VGND VPWR VPWR alu_result_out[14] sky130_fd_sc_hd__clkdlybuf4s25_1
X_5375_ _5375_/A0 _4806_/X _5383_/S VGND VGND VPWR VPWR _7145_/D sky130_fd_sc_hd__mux2_2
XFILLER_101_402 VGND VGND VPWR VPWR sky130_fd_sc_hd__decap_3
Xoutput499 _3394_/A VGND VGND VPWR VPWR instruction_out[16] sky130_fd_sc_hd__clkdlybuf4s25_1
Xoutput488 _3746_/C VGND VGND VPWR VPWR alu_result_out[5] sky130_fd_sc_hd__clkdlybuf4s25_1
X_4326_ _7013_/Q _4601_/S _4322_/X _4325_/X VGND VGND VPWR VPWR _4327_/B sky130_fd_sc_hd__a211o_2
XFILLER_99_474 VGND VGND VPWR VPWR sky130_fd_sc_hd__decap_3
XFILLER_101_435 VGND VGND VPWR VPWR sky130_fd_sc_hd__decap_3
XFILLER_113_284 VGND VGND VPWR VPWR sky130_fd_sc_hd__decap_3
XFILLER_59_349 VGND VGND VPWR VPWR sky130_fd_sc_hd__decap_3
XFILLER_86_124 VGND VGND VPWR VPWR sky130_fd_sc_hd__decap_3
XFILLER_87_669 VGND VGND VPWR VPWR sky130_fd_sc_hd__decap_3
X_7045_ _7230_/CLK _7045_/D _6325_/Y VGND VGND VPWR VPWR _7045_/Q sky130_fd_sc_hd__dfrtp_2
X_4257_ _4626_/B _4626_/C _4256_/C VGND VGND VPWR VPWR _4988_/B sky130_fd_sc_hd__a21oi_2
XFILLER_101_468 VGND VGND VPWR VPWR sky130_fd_sc_hd__decap_3
XFILLER_86_179 VGND VGND VPWR VPWR sky130_fd_sc_hd__decap_3
X_4188_ _7359_/Q _4196_/A2 _4187_/X _4419_/C1 VGND VGND VPWR VPWR _4188_/X sky130_fd_sc_hd__a211o_2
XFILLER_103_12 VGND VGND VPWR VPWR sky130_fd_sc_hd__decap_3
XFILLER_67_382 VGND VGND VPWR VPWR sky130_fd_sc_hd__decap_3
XFILLER_95_691 VGND VGND VPWR VPWR sky130_fd_sc_hd__fill_1
XFILLER_103_45 VGND VGND VPWR VPWR sky130_fd_sc_hd__decap_3
XFILLER_27_257 VGND VGND VPWR VPWR sky130_fd_sc_hd__decap_3
XFILLER_55_555 VGND VGND VPWR VPWR sky130_fd_sc_hd__decap_3
XFILLER_82_330 VGND VGND VPWR VPWR sky130_fd_sc_hd__decap_3
XFILLER_82_363 VGND VGND VPWR VPWR sky130_fd_sc_hd__fill_1
XFILLER_103_78 VGND VGND VPWR VPWR sky130_fd_sc_hd__decap_3
XFILLER_42_227 VGND VGND VPWR VPWR sky130_fd_sc_hd__decap_3
XFILLER_63_27 VGND VGND VPWR VPWR sky130_fd_sc_hd__decap_3
XFILLER_63_38 VGND VGND VPWR VPWR sky130_fd_sc_hd__decap_3
XFILLER_82_374 VGND VGND VPWR VPWR sky130_fd_sc_hd__decap_3
XFILLER_23_430 VGND VGND VPWR VPWR sky130_fd_sc_hd__decap_3
XFILLER_11_614 VGND VGND VPWR VPWR sky130_fd_sc_hd__fill_2
X_6829_ _6929_/CLK _6829_/D VGND VGND VPWR VPWR _6829_/Q sky130_fd_sc_hd__dfxtp_2
XFILLER_10_135 VGND VGND VPWR VPWR sky130_fd_sc_hd__decap_3
XFILLER_6_106 VGND VGND VPWR VPWR sky130_fd_sc_hd__decap_3
XFILLER_109_557 VGND VGND VPWR VPWR sky130_fd_sc_hd__decap_3
XFILLER_12_53 VGND VGND VPWR VPWR sky130_fd_sc_hd__decap_3
XFILLER_6_139 VGND VGND VPWR VPWR sky130_fd_sc_hd__fill_1
XFILLER_2_312 VGND VGND VPWR VPWR sky130_fd_sc_hd__decap_3
XFILLER_88_46 VGND VGND VPWR VPWR sky130_fd_sc_hd__decap_3
XFILLER_2_356 VGND VGND VPWR VPWR sky130_fd_sc_hd__decap_3
XFILLER_5_3 VGND VGND VPWR VPWR sky130_fd_sc_hd__decap_3
XFILLER_78_603 VGND VGND VPWR VPWR sky130_fd_sc_hd__decap_3
XFILLER_88_79 VGND VGND VPWR VPWR sky130_fd_sc_hd__decap_3
XFILLER_104_262 VGND VGND VPWR VPWR sky130_fd_sc_hd__decap_3
XFILLER_2_389 VGND VGND VPWR VPWR sky130_fd_sc_hd__decap_3
XFILLER_78_625 VGND VGND VPWR VPWR sky130_fd_sc_hd__decap_3
XFILLER_78_658 VGND VGND VPWR VPWR sky130_fd_sc_hd__decap_3
XFILLER_65_308 VGND VGND VPWR VPWR sky130_fd_sc_hd__decap_3
XFILLER_18_224 VGND VGND VPWR VPWR sky130_fd_sc_hd__decap_3
XFILLER_46_533 VGND VGND VPWR VPWR sky130_fd_sc_hd__decap_3
XFILLER_86_680 VGND VGND VPWR VPWR sky130_fd_sc_hd__decap_3
XFILLER_92_138 VGND VGND VPWR VPWR sky130_fd_sc_hd__fill_2
XFILLER_61_503 VGND VGND VPWR VPWR sky130_fd_sc_hd__fill_1
XFILLER_73_330 VGND VGND VPWR VPWR sky130_fd_sc_hd__decap_3
XFILLER_33_205 VGND VGND VPWR VPWR sky130_fd_sc_hd__decap_3
XFILLER_14_441 VGND VGND VPWR VPWR sky130_fd_sc_hd__fill_1
XTAP_TAPCELL_ROW_16_447 VGND VPWR sky130_fd_sc_hd__tapvpwrvgnd_1
XFILLER_53_60 VGND VGND VPWR VPWR sky130_fd_sc_hd__decap_3
XTAP_TAPCELL_ROW_44_778 VGND VPWR sky130_fd_sc_hd__tapvpwrvgnd_1
XFILLER_41_293 VGND VGND VPWR VPWR sky130_fd_sc_hd__decap_3
XFILLER_115_505 VGND VGND VPWR VPWR sky130_fd_sc_hd__fill_1
XFILLER_6_651 VGND VGND VPWR VPWR sky130_fd_sc_hd__decap_3
X_3490_ _7119_/Q _4235_/B1 _3489_/X _4248_/A VGND VGND VPWR VPWR _3490_/X sky130_fd_sc_hd__a211o_2
XFILLER_115_527 VGND VGND VPWR VPWR sky130_fd_sc_hd__decap_3
XFILLER_5_172 VGND VGND VPWR VPWR sky130_fd_sc_hd__decap_3
XFILLER_6_684 VGND VGND VPWR VPWR sky130_fd_sc_hd__decap_3
XFILLER_5_194 VGND VGND VPWR VPWR sky130_fd_sc_hd__decap_3
XFILLER_69_603 VGND VGND VPWR VPWR sky130_fd_sc_hd__decap_3
XFILLER_38_3 VGND VGND VPWR VPWR sky130_fd_sc_hd__decap_3
XFILLER_69_636 VGND VGND VPWR VPWR sky130_fd_sc_hd__decap_3
XFILLER_96_400 VGND VGND VPWR VPWR sky130_fd_sc_hd__decap_3
XPHY_EDGE_ROW_87_Left_204 VGND VGND VPWR VPWR sky130_fd_sc_hd__decap_3
XFILLER_110_232 VGND VGND VPWR VPWR sky130_fd_sc_hd__decap_3
XFILLER_69_647 VGND VGND VPWR VPWR sky130_fd_sc_hd__decap_3
XFILLER_96_455 VGND VGND VPWR VPWR sky130_fd_sc_hd__decap_3
X_5091_ _6985_/Q _5068_/C _6986_/Q VGND VGND VPWR VPWR _5092_/B sky130_fd_sc_hd__a21o_2
X_4111_ _4109_/X _4111_/B VGND VGND VPWR VPWR _4845_/A sky130_fd_sc_hd__nand2b_2
XFILLER_68_168 VGND VGND VPWR VPWR sky130_fd_sc_hd__decap_3
XFILLER_96_466 VGND VGND VPWR VPWR sky130_fd_sc_hd__decap_3
XFILLER_96_477 VGND VGND VPWR VPWR sky130_fd_sc_hd__decap_3
X_4042_ _7341_/Q _3947_/S _4437_/B1 _7373_/Q _4429_/C1 VGND VGND VPWR VPWR _4042_/X
+ sky130_fd_sc_hd__a221o_2
XFILLER_37_533 VGND VGND VPWR VPWR sky130_fd_sc_hd__decap_3
XFILLER_49_393 VGND VGND VPWR VPWR sky130_fd_sc_hd__decap_3
XFILLER_77_691 VGND VGND VPWR VPWR sky130_fd_sc_hd__fill_1
XFILLER_83_116 VGND VGND VPWR VPWR sky130_fd_sc_hd__decap_3
XFILLER_64_330 VGND VGND VPWR VPWR sky130_fd_sc_hd__fill_1
XFILLER_64_352 VGND VGND VPWR VPWR sky130_fd_sc_hd__fill_2
XFILLER_83_149 VGND VGND VPWR VPWR sky130_fd_sc_hd__decap_3
XFILLER_64_363 VGND VGND VPWR VPWR sky130_fd_sc_hd__fill_1
XFILLER_64_374 VGND VGND VPWR VPWR sky130_fd_sc_hd__decap_3
XFILLER_92_672 VGND VGND VPWR VPWR sky130_fd_sc_hd__decap_3
XTAP_TAPCELL_ROW_65_1028 VGND VPWR sky130_fd_sc_hd__tapvpwrvgnd_1
X_4944_ _5010_/A _4944_/B _4944_/C VGND VGND VPWR VPWR _4944_/X sky130_fd_sc_hd__or3_2
XPHY_EDGE_ROW_96_Left_213 VGND VGND VPWR VPWR sky130_fd_sc_hd__decap_3
X_4875_ _4842_/X _4871_/Y _4874_/X VGND VGND VPWR VPWR _5663_/C sky130_fd_sc_hd__a21bo_2
X_6614_ _6616_/A VGND VGND VPWR VPWR _6614_/Y sky130_fd_sc_hd__inv_2
X_3826_ _6731_/Q _5660_/B _3826_/B1 _6743_/Q _3825_/X VGND VGND VPWR VPWR _3826_/X
+ sky130_fd_sc_hd__a221o_2
X_6545_ _6578_/A VGND VGND VPWR VPWR _6545_/Y sky130_fd_sc_hd__inv_2
X_3757_ _3757_/A0 _3756_/X _4799_/A VGND VGND VPWR VPWR _7396_/D sky130_fd_sc_hd__mux2_2
XFILLER_106_527 VGND VGND VPWR VPWR sky130_fd_sc_hd__decap_3
XFILLER_109_9 VGND VGND VPWR VPWR sky130_fd_sc_hd__decap_3
X_6476_ _6644_/A VGND VGND VPWR VPWR _6476_/Y sky130_fd_sc_hd__inv_2
X_5427_ _5427_/A0 _5156_/X _5429_/S VGND VGND VPWR VPWR _7120_/D sky130_fd_sc_hd__mux2_2
XTAP_TAPCELL_ROW_76_1168 VGND VPWR sky130_fd_sc_hd__tapvpwrvgnd_1
XFILLER_114_560 VGND VGND VPWR VPWR sky130_fd_sc_hd__decap_3
XFILLER_58_16 VGND VGND VPWR VPWR sky130_fd_sc_hd__decap_3
XFILLER_58_38 VGND VGND VPWR VPWR sky130_fd_sc_hd__decap_3
XFILLER_87_400 VGND VGND VPWR VPWR sky130_fd_sc_hd__fill_1
X_5358_ _5358_/A0 _5156_/X _5360_/S VGND VGND VPWR VPWR _7152_/D sky130_fd_sc_hd__mux2_2
XFILLER_87_433 VGND VGND VPWR VPWR sky130_fd_sc_hd__decap_3
X_4309_ _7128_/Q _3407_/X _4307_/X _4308_/X VGND VGND VPWR VPWR _4311_/B sky130_fd_sc_hd__a211o_2
XFILLER_99_293 VGND VGND VPWR VPWR sky130_fd_sc_hd__decap_3
XFILLER_74_105 VGND VGND VPWR VPWR sky130_fd_sc_hd__decap_3
X_7028_ _7386_/CLK _7028_/D _6308_/Y VGND VGND VPWR VPWR _7028_/Q sky130_fd_sc_hd__dfrtp_2
XFILLER_114_44 VGND VGND VPWR VPWR sky130_fd_sc_hd__decap_3
XFILLER_28_533 VGND VGND VPWR VPWR sky130_fd_sc_hd__decap_3
XFILLER_114_77 VGND VGND VPWR VPWR sky130_fd_sc_hd__decap_3
XFILLER_114_88 VGND VGND VPWR VPWR sky130_fd_sc_hd__decap_3
XFILLER_55_330 VGND VGND VPWR VPWR sky130_fd_sc_hd__decap_3
XFILLER_74_26 VGND VGND VPWR VPWR sky130_fd_sc_hd__fill_2
XFILLER_15_205 VGND VGND VPWR VPWR sky130_fd_sc_hd__decap_3
XFILLER_15_249 VGND VGND VPWR VPWR sky130_fd_sc_hd__decap_3
XTAP_TAPCELL_ROW_87_1297 VGND VPWR sky130_fd_sc_hd__tapvpwrvgnd_1
XFILLER_90_14 VGND VGND VPWR VPWR sky130_fd_sc_hd__decap_3
XTAP_TAPCELL_ROW_13_406 VGND VPWR sky130_fd_sc_hd__tapvpwrvgnd_1
XFILLER_11_411 VGND VGND VPWR VPWR sky130_fd_sc_hd__decap_3
XFILLER_23_271 VGND VGND VPWR VPWR sky130_fd_sc_hd__decap_3
XFILLER_23_30 VGND VGND VPWR VPWR sky130_fd_sc_hd__fill_2
XFILLER_70_399 VGND VGND VPWR VPWR sky130_fd_sc_hd__decap_3
XFILLER_90_47 VGND VGND VPWR VPWR sky130_fd_sc_hd__decap_3
XTAP_TAPCELL_ROW_41_748 VGND VPWR sky130_fd_sc_hd__tapvpwrvgnd_1
XFILLER_23_63 VGND VGND VPWR VPWR sky130_fd_sc_hd__decap_3
XFILLER_99_12 VGND VGND VPWR VPWR sky130_fd_sc_hd__decap_3
XFILLER_99_78 VGND VGND VPWR VPWR sky130_fd_sc_hd__decap_3
XFILLER_3_632 VGND VGND VPWR VPWR sky130_fd_sc_hd__decap_3
XFILLER_2_153 VGND VGND VPWR VPWR sky130_fd_sc_hd__decap_3
XFILLER_3_665 VGND VGND VPWR VPWR sky130_fd_sc_hd__decap_3
XFILLER_3_676 VGND VGND VPWR VPWR sky130_fd_sc_hd__decap_3
XFILLER_97_219 VGND VGND VPWR VPWR sky130_fd_sc_hd__decap_3
XFILLER_105_582 VGND VGND VPWR VPWR sky130_fd_sc_hd__decap_3
XFILLER_78_433 VGND VGND VPWR VPWR sky130_fd_sc_hd__decap_3
XFILLER_66_628 VGND VGND VPWR VPWR sky130_fd_sc_hd__decap_3
XFILLER_78_477 VGND VGND VPWR VPWR sky130_fd_sc_hd__decap_3
XFILLER_19_522 VGND VGND VPWR VPWR sky130_fd_sc_hd__fill_1
XFILLER_59_691 VGND VGND VPWR VPWR sky130_fd_sc_hd__fill_1
XFILLER_65_116 VGND VGND VPWR VPWR sky130_fd_sc_hd__decap_3
XFILLER_65_138 VGND VGND VPWR VPWR sky130_fd_sc_hd__decap_3
Xsingle_cycle_cpu_578 VGND VGND VPWR VPWR single_cycle_cpu_578/HI instruction_out[31]
+ sky130_fd_sc_hd__conb_1
XTAP_TAPCELL_ROW_49_837 VGND VPWR sky130_fd_sc_hd__tapvpwrvgnd_1
XFILLER_46_341 VGND VGND VPWR VPWR sky130_fd_sc_hd__decap_3
XFILLER_93_458 VGND VGND VPWR VPWR sky130_fd_sc_hd__decap_3
XFILLER_61_311 VGND VGND VPWR VPWR sky130_fd_sc_hd__decap_3
XFILLER_0_89 VGND VGND VPWR VPWR sky130_fd_sc_hd__decap_3
XTAP_TAPCELL_ROW_29_594 VGND VPWR sky130_fd_sc_hd__tapvpwrvgnd_1
XFILLER_21_208 VGND VGND VPWR VPWR sky130_fd_sc_hd__decap_3
XFILLER_61_366 VGND VGND VPWR VPWR sky130_fd_sc_hd__decap_3
XFILLER_9_21 VGND VGND VPWR VPWR sky130_fd_sc_hd__decap_3
XFILLER_61_399 VGND VGND VPWR VPWR sky130_fd_sc_hd__decap_3
XFILLER_9_54 VGND VGND VPWR VPWR sky130_fd_sc_hd__fill_2
XFILLER_14_293 VGND VGND VPWR VPWR sky130_fd_sc_hd__decap_3
X_4660_ _4720_/A _4655_/X _4658_/A VGND VGND VPWR VPWR _4660_/X sky130_fd_sc_hd__a21bo_2
XFILLER_9_87 VGND VGND VPWR VPWR sky130_fd_sc_hd__decap_3
XFILLER_80_91 VGND VGND VPWR VPWR sky130_fd_sc_hd__fill_2
X_3611_ _5057_/A _3611_/B VGND VGND VPWR VPWR _3611_/Y sky130_fd_sc_hd__nor2_2
XFILLER_9_98 VGND VGND VPWR VPWR sky130_fd_sc_hd__decap_3
X_6330_ _6682_/A VGND VGND VPWR VPWR _6330_/Y sky130_fd_sc_hd__inv_2
X_4591_ _7285_/Q _4595_/B VGND VGND VPWR VPWR _7285_/D sky130_fd_sc_hd__and2_2
XFILLER_115_302 VGND VGND VPWR VPWR sky130_fd_sc_hd__decap_3
Xhold905 _6702_/Q VGND VGND VPWR VPWR hold905/X sky130_fd_sc_hd__dlygate4sd3_1
Xhold916 _6715_/Q VGND VGND VPWR VPWR hold916/X sky130_fd_sc_hd__dlygate4sd3_1
Xhold927 _7031_/Q VGND VGND VPWR VPWR _5593_/A sky130_fd_sc_hd__dlygate4sd3_1
XFILLER_103_508 VGND VGND VPWR VPWR sky130_fd_sc_hd__decap_3
XFILLER_115_346 VGND VGND VPWR VPWR sky130_fd_sc_hd__decap_3
Xhold949 _6712_/Q VGND VGND VPWR VPWR hold949/X sky130_fd_sc_hd__dlygate4sd3_1
Xhold938 _6711_/Q VGND VGND VPWR VPWR hold938/X sky130_fd_sc_hd__dlygate4sd3_1
X_6261_ _6385_/A VGND VGND VPWR VPWR _6261_/Y sky130_fd_sc_hd__inv_2
X_3473_ _7312_/Q _3973_/S _4332_/B1 _7344_/Q _3556_/A VGND VGND VPWR VPWR _3473_/X
+ sky130_fd_sc_hd__a221o_2
XFILLER_57_617 VGND VGND VPWR VPWR sky130_fd_sc_hd__decap_3
XFILLER_111_585 VGND VGND VPWR VPWR sky130_fd_sc_hd__decap_3
XFILLER_56_127 VGND VGND VPWR VPWR sky130_fd_sc_hd__decap_3
XFILLER_84_414 VGND VGND VPWR VPWR sky130_fd_sc_hd__decap_3
XFILLER_84_436 VGND VGND VPWR VPWR sky130_fd_sc_hd__decap_3
XFILLER_96_296 VGND VGND VPWR VPWR sky130_fd_sc_hd__decap_3
X_5074_ _4852_/A _5073_/A _5073_/Y _5146_/B1 VGND VGND VPWR VPWR _5075_/C sky130_fd_sc_hd__a2bb2o_2
XTAP_TAPCELL_ROW_71_1098 VGND VPWR sky130_fd_sc_hd__tapvpwrvgnd_1
XFILLER_65_650 VGND VGND VPWR VPWR sky130_fd_sc_hd__decap_3
XFILLER_37_374 VGND VGND VPWR VPWR sky130_fd_sc_hd__decap_3
XFILLER_37_385 VGND VGND VPWR VPWR sky130_fd_sc_hd__decap_3
XFILLER_25_536 VGND VGND VPWR VPWR sky130_fd_sc_hd__fill_1
XFILLER_44_18 VGND VGND VPWR VPWR sky130_fd_sc_hd__decap_3
XFILLER_52_333 VGND VGND VPWR VPWR sky130_fd_sc_hd__decap_3
XFILLER_64_193 VGND VGND VPWR VPWR sky130_fd_sc_hd__decap_3
XFILLER_80_642 VGND VGND VPWR VPWR sky130_fd_sc_hd__fill_2
XFILLER_92_480 VGND VGND VPWR VPWR sky130_fd_sc_hd__decap_3
XFILLER_80_675 VGND VGND VPWR VPWR sky130_fd_sc_hd__decap_3
XFILLER_100_24 VGND VGND VPWR VPWR sky130_fd_sc_hd__decap_3
XFILLER_100_35 VGND VGND VPWR VPWR sky130_fd_sc_hd__decap_3
X_4927_ _5581_/S _4927_/B _5656_/C VGND VGND VPWR VPWR _4927_/X sky130_fd_sc_hd__or3_2
XFILLER_100_68 VGND VGND VPWR VPWR sky130_fd_sc_hd__decap_3
XFILLER_20_230 VGND VGND VPWR VPWR sky130_fd_sc_hd__fill_1
X_4858_ _6999_/Q _4858_/B VGND VGND VPWR VPWR _4870_/A sky130_fd_sc_hd__and2_2
XFILLER_20_263 VGND VGND VPWR VPWR sky130_fd_sc_hd__decap_3
X_3809_ _6836_/Q _3891_/A2 _3892_/B1 _6841_/Q VGND VGND VPWR VPWR _3809_/X sky130_fd_sc_hd__a22o_2
XFILLER_20_285 VGND VGND VPWR VPWR sky130_fd_sc_hd__fill_2
X_4789_ _5057_/A _4412_/B _4413_/A _4852_/A _4788_/Y VGND VGND VPWR VPWR _4789_/X
+ sky130_fd_sc_hd__o221a_2
XFILLER_106_324 VGND VGND VPWR VPWR sky130_fd_sc_hd__decap_3
XFILLER_109_33 VGND VGND VPWR VPWR sky130_fd_sc_hd__decap_3
X_6528_ _6640_/A VGND VGND VPWR VPWR _6528_/Y sky130_fd_sc_hd__inv_2
XFILLER_109_66 VGND VGND VPWR VPWR sky130_fd_sc_hd__decap_3
XFILLER_109_99 VGND VGND VPWR VPWR sky130_fd_sc_hd__decap_3
XFILLER_69_15 VGND VGND VPWR VPWR sky130_fd_sc_hd__decap_3
XFILLER_69_48 VGND VGND VPWR VPWR sky130_fd_sc_hd__decap_3
X_6459_ _6558_/A VGND VGND VPWR VPWR _6459_/Y sky130_fd_sc_hd__inv_2
XFILLER_79_208 VGND VGND VPWR VPWR sky130_fd_sc_hd__decap_3
XFILLER_79_219 VGND VGND VPWR VPWR sky130_fd_sc_hd__decap_3
XFILLER_0_657 VGND VGND VPWR VPWR sky130_fd_sc_hd__decap_3
XFILLER_48_606 VGND VGND VPWR VPWR sky130_fd_sc_hd__decap_3
XFILLER_85_14 VGND VGND VPWR VPWR sky130_fd_sc_hd__decap_3
XFILLER_87_252 VGND VGND VPWR VPWR sky130_fd_sc_hd__decap_3
XFILLER_48_639 VGND VGND VPWR VPWR sky130_fd_sc_hd__decap_3
XFILLER_75_414 VGND VGND VPWR VPWR sky130_fd_sc_hd__decap_3
XFILLER_85_36 VGND VGND VPWR VPWR sky130_fd_sc_hd__decap_3
XTAP_TAPCELL_ROW_89_1315 VGND VPWR sky130_fd_sc_hd__tapvpwrvgnd_1
XFILLER_18_41 VGND VGND VPWR VPWR sky130_fd_sc_hd__decap_3
XFILLER_75_447 VGND VGND VPWR VPWR sky130_fd_sc_hd__fill_1
XFILLER_75_458 VGND VGND VPWR VPWR sky130_fd_sc_hd__decap_3
XTAP_TAPCELL_ROW_46_807 VGND VPWR sky130_fd_sc_hd__tapvpwrvgnd_1
XFILLER_18_74 VGND VGND VPWR VPWR sky130_fd_sc_hd__decap_3
XFILLER_28_352 VGND VGND VPWR VPWR sky130_fd_sc_hd__decap_3
XFILLER_56_672 VGND VGND VPWR VPWR sky130_fd_sc_hd__decap_3
XFILLER_90_406 VGND VGND VPWR VPWR sky130_fd_sc_hd__fill_1
XFILLER_16_536 VGND VGND VPWR VPWR sky130_fd_sc_hd__decap_3
XFILLER_71_620 VGND VGND VPWR VPWR sky130_fd_sc_hd__fill_1
XFILLER_71_653 VGND VGND VPWR VPWR sky130_fd_sc_hd__decap_3
XFILLER_43_366 VGND VGND VPWR VPWR sky130_fd_sc_hd__fill_2
XFILLER_43_377 VGND VGND VPWR VPWR sky130_fd_sc_hd__decap_3
XFILLER_70_141 VGND VGND VPWR VPWR sky130_fd_sc_hd__decap_3
XTAP_TAPCELL_ROW_26_564 VGND VPWR sky130_fd_sc_hd__tapvpwrvgnd_1
XTAP_TAPCELL_ROW_54_895 VGND VPWR sky130_fd_sc_hd__tapvpwrvgnd_1
XFILLER_11_263 VGND VGND VPWR VPWR sky130_fd_sc_hd__decap_3
XFILLER_7_212 VGND VGND VPWR VPWR sky130_fd_sc_hd__decap_3
XFILLER_50_50 VGND VGND VPWR VPWR sky130_fd_sc_hd__decap_3
XFILLER_7_234 VGND VGND VPWR VPWR sky130_fd_sc_hd__decap_3
XFILLER_50_94 VGND VGND VPWR VPWR sky130_fd_sc_hd__decap_3
XFILLER_98_506 VGND VGND VPWR VPWR sky130_fd_sc_hd__decap_3
XFILLER_98_528 VGND VGND VPWR VPWR sky130_fd_sc_hd__decap_3
XFILLER_105_390 VGND VGND VPWR VPWR sky130_fd_sc_hd__fill_2
XFILLER_112_349 VGND VGND VPWR VPWR sky130_fd_sc_hd__decap_3
XFILLER_3_484 VGND VGND VPWR VPWR sky130_fd_sc_hd__fill_1
XFILLER_22_6 VGND VGND VPWR VPWR sky130_fd_sc_hd__decap_3
XFILLER_78_241 VGND VGND VPWR VPWR sky130_fd_sc_hd__fill_1
XFILLER_38_105 VGND VGND VPWR VPWR sky130_fd_sc_hd__fill_2
XFILLER_38_127 VGND VGND VPWR VPWR sky130_fd_sc_hd__decap_3
XFILLER_78_285 VGND VGND VPWR VPWR sky130_fd_sc_hd__decap_3
XFILLER_47_650 VGND VGND VPWR VPWR sky130_fd_sc_hd__decap_3
XFILLER_19_352 VGND VGND VPWR VPWR sky130_fd_sc_hd__decap_3
XFILLER_93_288 VGND VGND VPWR VPWR sky130_fd_sc_hd__decap_3
XTAP_TAPCELL_ROW_109_1562 VGND VPWR sky130_fd_sc_hd__tapvpwrvgnd_1
XFILLER_46_171 VGND VGND VPWR VPWR sky130_fd_sc_hd__decap_3
XFILLER_62_620 VGND VGND VPWR VPWR sky130_fd_sc_hd__decap_3
XFILLER_74_480 VGND VGND VPWR VPWR sky130_fd_sc_hd__decap_3
XFILLER_34_355 VGND VGND VPWR VPWR sky130_fd_sc_hd__decap_3
XFILLER_61_141 VGND VGND VPWR VPWR sky130_fd_sc_hd__fill_1
XFILLER_62_675 VGND VGND VPWR VPWR sky130_fd_sc_hd__decap_3
XFILLER_61_196 VGND VGND VPWR VPWR sky130_fd_sc_hd__decap_3
X_4712_ _7007_/Q _4738_/A VGND VGND VPWR VPWR _4731_/B sky130_fd_sc_hd__nand2_2
XFILLER_30_561 VGND VGND VPWR VPWR sky130_fd_sc_hd__fill_2
X_4643_ _4888_/A _4125_/X _4126_/A VGND VGND VPWR VPWR _4643_/Y sky130_fd_sc_hd__a21oi_2
X_7362_ _7365_/CLK _7362_/D _6642_/Y VGND VGND VPWR VPWR _7362_/Q sky130_fd_sc_hd__dfrtp_2
Xhold702 _6811_/Q VGND VGND VPWR VPWR _6811_/D sky130_fd_sc_hd__dlygate4sd3_1
X_7293_ _7386_/CLK _7293_/D _6573_/Y VGND VGND VPWR VPWR _7293_/Q sky130_fd_sc_hd__dfrtp_2
Xhold713 _6719_/Q VGND VGND VPWR VPWR _6719_/D sky130_fd_sc_hd__dlygate4sd3_1
Xhold724 _6955_/Q VGND VGND VPWR VPWR _6955_/D sky130_fd_sc_hd__dlygate4sd3_1
Xhold735 _6803_/Q VGND VGND VPWR VPWR _6803_/D sky130_fd_sc_hd__dlygate4sd3_1
Xhold746 _6901_/Q VGND VGND VPWR VPWR _6901_/D sky130_fd_sc_hd__dlygate4sd3_1
X_6313_ _6660_/A VGND VGND VPWR VPWR _6313_/Y sky130_fd_sc_hd__inv_2
X_3525_ _3525_/A _3525_/B VGND VGND VPWR VPWR _5072_/A sky130_fd_sc_hd__and2_2
XFILLER_103_316 VGND VGND VPWR VPWR sky130_fd_sc_hd__decap_3
XFILLER_115_143 VGND VGND VPWR VPWR sky130_fd_sc_hd__decap_3
Xhold757 _6947_/Q VGND VGND VPWR VPWR _6947_/D sky130_fd_sc_hd__dlygate4sd3_1
Xhold768 _6777_/Q VGND VGND VPWR VPWR _6777_/D sky130_fd_sc_hd__dlygate4sd3_1
Xhold779 _6781_/Q VGND VGND VPWR VPWR _6781_/D sky130_fd_sc_hd__dlygate4sd3_1
XTAP_TAPCELL_ROW_73_1127 VGND VPWR sky130_fd_sc_hd__tapvpwrvgnd_1
XFILLER_115_187 VGND VGND VPWR VPWR sky130_fd_sc_hd__decap_3
X_3456_ _7011_/Q _3358_/X _3448_/X _3455_/X VGND VGND VPWR VPWR _3456_/X sky130_fd_sc_hd__a211o_2
X_3387_ _3385_/Y _3386_/Y _3977_/S _3399_/B VGND VGND VPWR VPWR _3429_/B sky130_fd_sc_hd__a211o_2
XFILLER_29_116 VGND VGND VPWR VPWR sky130_fd_sc_hd__decap_3
XFILLER_69_263 VGND VGND VPWR VPWR sky130_fd_sc_hd__decap_3
X_5126_ _5126_/A0 _5125_/Y _5126_/S VGND VGND VPWR VPWR _7253_/D sky130_fd_sc_hd__mux2_2
XFILLER_84_233 VGND VGND VPWR VPWR sky130_fd_sc_hd__decap_3
X_5057_ _5057_/A _5057_/B VGND VGND VPWR VPWR _5057_/Y sky130_fd_sc_hd__nor2_2
XFILLER_38_683 VGND VGND VPWR VPWR sky130_fd_sc_hd__decap_3
XFILLER_44_108 VGND VGND VPWR VPWR sky130_fd_sc_hd__decap_3
XFILLER_84_266 VGND VGND VPWR VPWR sky130_fd_sc_hd__fill_1
XFILLER_84_288 VGND VGND VPWR VPWR sky130_fd_sc_hd__decap_3
XFILLER_111_12 VGND VGND VPWR VPWR sky130_fd_sc_hd__fill_1
XFILLER_37_193 VGND VGND VPWR VPWR sky130_fd_sc_hd__decap_3
XFILLER_53_620 VGND VGND VPWR VPWR sky130_fd_sc_hd__decap_3
XFILLER_72_439 VGND VGND VPWR VPWR sky130_fd_sc_hd__decap_3
XFILLER_111_34 VGND VGND VPWR VPWR sky130_fd_sc_hd__decap_3
XFILLER_25_355 VGND VGND VPWR VPWR sky130_fd_sc_hd__decap_3
XFILLER_52_141 VGND VGND VPWR VPWR sky130_fd_sc_hd__decap_3
XFILLER_53_664 VGND VGND VPWR VPWR sky130_fd_sc_hd__decap_3
XTAP_TAPCELL_ROW_84_1256 VGND VPWR sky130_fd_sc_hd__tapvpwrvgnd_1
XFILLER_111_78 VGND VGND VPWR VPWR sky130_fd_sc_hd__decap_3
XFILLER_25_399 VGND VGND VPWR VPWR sky130_fd_sc_hd__decap_3
XFILLER_52_174 VGND VGND VPWR VPWR sky130_fd_sc_hd__decap_3
XFILLER_80_472 VGND VGND VPWR VPWR sky130_fd_sc_hd__decap_3
XTAP_TAPCELL_ROW_23_523 VGND VPWR sky130_fd_sc_hd__tapvpwrvgnd_1
XFILLER_71_49 VGND VGND VPWR VPWR sky130_fd_sc_hd__decap_3
XTAP_TAPCELL_ROW_51_865 VGND VPWR sky130_fd_sc_hd__tapvpwrvgnd_1
XFILLER_4_215 VGND VGND VPWR VPWR sky130_fd_sc_hd__decap_3
XFILLER_105_3 VGND VGND VPWR VPWR sky130_fd_sc_hd__decap_3
XFILLER_106_132 VGND VGND VPWR VPWR sky130_fd_sc_hd__fill_2
XFILLER_107_644 VGND VGND VPWR VPWR sky130_fd_sc_hd__decap_3
XFILLER_107_688 VGND VGND VPWR VPWR sky130_fd_sc_hd__decap_3
XFILLER_20_53 VGND VGND VPWR VPWR sky130_fd_sc_hd__fill_2
XTAP_TAPCELL_ROW_95_1396 VGND VPWR sky130_fd_sc_hd__tapvpwrvgnd_1
XFILLER_0_421 VGND VGND VPWR VPWR sky130_fd_sc_hd__decap_3
XFILLER_20_97 VGND VGND VPWR VPWR sky130_fd_sc_hd__decap_3
XFILLER_96_35 VGND VGND VPWR VPWR sky130_fd_sc_hd__decap_3
XFILLER_88_561 VGND VGND VPWR VPWR sky130_fd_sc_hd__decap_3
XFILLER_102_371 VGND VGND VPWR VPWR sky130_fd_sc_hd__decap_3
XFILLER_75_200 VGND VGND VPWR VPWR sky130_fd_sc_hd__decap_3
XPHY_EDGE_ROW_42_Left_159 VGND VGND VPWR VPWR sky130_fd_sc_hd__decap_3
XFILLER_29_84 VGND VGND VPWR VPWR sky130_fd_sc_hd__decap_3
XFILLER_48_458 VGND VGND VPWR VPWR sky130_fd_sc_hd__fill_2
XFILLER_48_469 VGND VGND VPWR VPWR sky130_fd_sc_hd__decap_3
XTAP_TAPCELL_ROW_59_965 VGND VPWR sky130_fd_sc_hd__tapvpwrvgnd_1
XTAP_TAPCELL_ROW_59_954 VGND VPWR sky130_fd_sc_hd__tapvpwrvgnd_1
XFILLER_16_300 VGND VGND VPWR VPWR sky130_fd_sc_hd__decap_3
XFILLER_44_642 VGND VGND VPWR VPWR sky130_fd_sc_hd__fill_2
XFILLER_63_439 VGND VGND VPWR VPWR sky130_fd_sc_hd__decap_3
XFILLER_75_299 VGND VGND VPWR VPWR sky130_fd_sc_hd__fill_1
XFILLER_90_236 VGND VGND VPWR VPWR sky130_fd_sc_hd__decap_3
Xplace406 _4532_/S VGND VGND VPWR VPWR _4528_/B sky130_fd_sc_hd__buf_2
Xplace417 _3949_/S VGND VGND VPWR VPWR _3947_/S sky130_fd_sc_hd__buf_2
Xplace428 _3371_/Y VGND VGND VPWR VPWR _4268_/A2 sky130_fd_sc_hd__buf_2
XTAP_TAPCELL_ROW_3_292 VGND VPWR sky130_fd_sc_hd__tapvpwrvgnd_1
XFILLER_44_675 VGND VGND VPWR VPWR sky130_fd_sc_hd__decap_3
XFILLER_90_269 VGND VGND VPWR VPWR sky130_fd_sc_hd__decap_3
Xplace439 _4467_/Y VGND VGND VPWR VPWR _5015_/A sky130_fd_sc_hd__buf_2
XFILLER_71_472 VGND VGND VPWR VPWR sky130_fd_sc_hd__decap_3
XFILLER_31_369 VGND VGND VPWR VPWR sky130_fd_sc_hd__decap_3
XFILLER_91_9 VGND VGND VPWR VPWR sky130_fd_sc_hd__decap_3
XPHY_EDGE_ROW_51_Left_168 VGND VGND VPWR VPWR sky130_fd_sc_hd__decap_3
XFILLER_61_60 VGND VGND VPWR VPWR sky130_fd_sc_hd__decap_3
XFILLER_61_93 VGND VGND VPWR VPWR sky130_fd_sc_hd__decap_3
XFILLER_8_587 VGND VGND VPWR VPWR sky130_fd_sc_hd__fill_1
XANTENNA_4 _4799_/A VGND VGND VPWR VPWR sky130_fd_sc_hd__diode_2
XFILLER_6_44 VGND VGND VPWR VPWR sky130_fd_sc_hd__decap_3
XFILLER_113_603 VGND VGND VPWR VPWR sky130_fd_sc_hd__decap_3
XFILLER_6_77 VGND VGND VPWR VPWR sky130_fd_sc_hd__decap_3
XFILLER_6_88 VGND VGND VPWR VPWR sky130_fd_sc_hd__decap_3
X_3310_ _5118_/C _3519_/B _3383_/B _3330_/A VGND VGND VPWR VPWR _3310_/Y sky130_fd_sc_hd__a31oi_2
XFILLER_98_303 VGND VGND VPWR VPWR sky130_fd_sc_hd__decap_3
XFILLER_112_124 VGND VGND VPWR VPWR sky130_fd_sc_hd__decap_3
XFILLER_113_647 VGND VGND VPWR VPWR sky130_fd_sc_hd__decap_3
X_4290_ _4283_/X _4288_/X _5647_/B _4649_/A VGND VGND VPWR VPWR _4612_/B sky130_fd_sc_hd__a2bb2o_4
XFILLER_98_336 VGND VGND VPWR VPWR sky130_fd_sc_hd__decap_3
XFILLER_112_168 VGND VGND VPWR VPWR sky130_fd_sc_hd__decap_3
XPHY_EDGE_ROW_60_Left_177 VGND VGND VPWR VPWR sky130_fd_sc_hd__decap_3
XFILLER_20_3 VGND VGND VPWR VPWR sky130_fd_sc_hd__decap_3
XFILLER_94_520 VGND VGND VPWR VPWR sky130_fd_sc_hd__fill_2
XFILLER_39_447 VGND VGND VPWR VPWR sky130_fd_sc_hd__fill_1
XFILLER_94_542 VGND VGND VPWR VPWR sky130_fd_sc_hd__fill_1
XFILLER_54_417 VGND VGND VPWR VPWR sky130_fd_sc_hd__decap_3
XFILLER_66_277 VGND VGND VPWR VPWR sky130_fd_sc_hd__decap_3
XFILLER_94_575 VGND VGND VPWR VPWR sky130_fd_sc_hd__decap_3
XFILLER_94_597 VGND VGND VPWR VPWR sky130_fd_sc_hd__fill_2
XFILLER_35_642 VGND VGND VPWR VPWR sky130_fd_sc_hd__decap_3
XFILLER_81_225 VGND VGND VPWR VPWR sky130_fd_sc_hd__fill_1
XFILLER_81_247 VGND VGND VPWR VPWR sky130_fd_sc_hd__fill_1
X_6931_ _6931_/CLK _6931_/D VGND VGND VPWR VPWR _6931_/Q sky130_fd_sc_hd__dfxtp_2
XFILLER_19_193 VGND VGND VPWR VPWR sky130_fd_sc_hd__decap_3
XFILLER_34_141 VGND VGND VPWR VPWR sky130_fd_sc_hd__decap_3
X_6862_ _6976_/CLK _6862_/D VGND VGND VPWR VPWR _6862_/Q sky130_fd_sc_hd__dfxtp_2
XFILLER_22_325 VGND VGND VPWR VPWR sky130_fd_sc_hd__fill_1
XFILLER_34_174 VGND VGND VPWR VPWR sky130_fd_sc_hd__decap_3
XFILLER_50_612 VGND VGND VPWR VPWR sky130_fd_sc_hd__decap_3
XFILLER_50_645 VGND VGND VPWR VPWR sky130_fd_sc_hd__decap_3
X_6793_ _6929_/CLK _6793_/D VGND VGND VPWR VPWR _6793_/Q sky130_fd_sc_hd__dfxtp_2
XFILLER_50_678 VGND VGND VPWR VPWR sky130_fd_sc_hd__decap_3
X_4626_ _4256_/C _4626_/B _4626_/C VGND VGND VPWR VPWR _4626_/X sky130_fd_sc_hd__and3b_2
X_7345_ clkload4/A _7345_/D _6625_/Y VGND VGND VPWR VPWR _7345_/Q sky130_fd_sc_hd__dfrtp_2
XFILLER_116_452 VGND VGND VPWR VPWR sky130_fd_sc_hd__decap_3
XFILLER_89_303 VGND VGND VPWR VPWR sky130_fd_sc_hd__decap_3
X_7276_ _7372_/CLK _7276_/D _6556_/Y VGND VGND VPWR VPWR _7276_/Q sky130_fd_sc_hd__dfrtp_2
Xhold587 _6912_/Q VGND VGND VPWR VPWR _6912_/D sky130_fd_sc_hd__dlygate4sd3_1
X_4488_ _4488_/A0 _7303_/Q _4488_/S VGND VGND VPWR VPWR _7335_/D sky130_fd_sc_hd__mux2_2
X_3508_ _3508_/A _3508_/B VGND VGND VPWR VPWR _3508_/Y sky130_fd_sc_hd__nor2_2
XFILLER_103_135 VGND VGND VPWR VPWR sky130_fd_sc_hd__decap_3
XFILLER_104_669 VGND VGND VPWR VPWR sky130_fd_sc_hd__decap_3
XFILLER_106_12 VGND VGND VPWR VPWR sky130_fd_sc_hd__decap_3
Xhold598 _6939_/Q VGND VGND VPWR VPWR _6939_/D sky130_fd_sc_hd__dlygate4sd3_1
X_3439_ _7282_/Q _4532_/S _4339_/B1 _7154_/Q _3438_/X VGND VGND VPWR VPWR _3439_/X
+ sky130_fd_sc_hd__a221o_2
XFILLER_106_56 VGND VGND VPWR VPWR sky130_fd_sc_hd__decap_3
XFILLER_66_27 VGND VGND VPWR VPWR sky130_fd_sc_hd__fill_1
XFILLER_18_609 VGND VGND VPWR VPWR sky130_fd_sc_hd__fill_1
XFILLER_57_233 VGND VGND VPWR VPWR sky130_fd_sc_hd__fill_1
Xhold1210 _7122_/Q VGND VGND VPWR VPWR _5423_/A0 sky130_fd_sc_hd__dlygate4sd3_1
XFILLER_45_406 VGND VGND VPWR VPWR sky130_fd_sc_hd__decap_3
XFILLER_85_564 VGND VGND VPWR VPWR sky130_fd_sc_hd__decap_3
XTAP_TAPCELL_ROW_56_924 VGND VPWR sky130_fd_sc_hd__tapvpwrvgnd_1
XFILLER_57_299 VGND VGND VPWR VPWR sky130_fd_sc_hd__fill_1
XFILLER_85_597 VGND VGND VPWR VPWR sky130_fd_sc_hd__decap_3
XFILLER_72_247 VGND VGND VPWR VPWR sky130_fd_sc_hd__decap_3
XTAP_TAPCELL_ROW_0_251 VGND VPWR sky130_fd_sc_hd__tapvpwrvgnd_1
XTAP_TAPCELL_ROW_0_240 VGND VPWR sky130_fd_sc_hd__tapvpwrvgnd_1
XFILLER_25_152 VGND VGND VPWR VPWR sky130_fd_sc_hd__fill_1
XFILLER_40_100 VGND VGND VPWR VPWR sky130_fd_sc_hd__decap_3
XFILLER_41_612 VGND VGND VPWR VPWR sky130_fd_sc_hd__decap_3
XFILLER_82_59 VGND VGND VPWR VPWR sky130_fd_sc_hd__decap_3
XTAP_TAPCELL_ROW_36_681 VGND VPWR sky130_fd_sc_hd__tapvpwrvgnd_1
XFILLER_15_42 VGND VGND VPWR VPWR sky130_fd_sc_hd__decap_3
XFILLER_40_144 VGND VGND VPWR VPWR sky130_fd_sc_hd__decap_3
XFILLER_41_656 VGND VGND VPWR VPWR sky130_fd_sc_hd__decap_3
XFILLER_40_177 VGND VGND VPWR VPWR sky130_fd_sc_hd__decap_3
XTAP_TAPCELL_ROW_97_1414 VGND VPWR sky130_fd_sc_hd__tapvpwrvgnd_1
XFILLER_31_63 VGND VGND VPWR VPWR sky130_fd_sc_hd__decap_3
XFILLER_107_452 VGND VGND VPWR VPWR sky130_fd_sc_hd__fill_2
XTAP_TAPCELL_ROW_8_351 VGND VPWR sky130_fd_sc_hd__tapvpwrvgnd_1
XFILLER_0_262 VGND VGND VPWR VPWR sky130_fd_sc_hd__decap_3
XFILLER_110_628 VGND VGND VPWR VPWR sky130_fd_sc_hd__decap_3
XFILLER_48_200 VGND VGND VPWR VPWR sky130_fd_sc_hd__decap_3
XFILLER_76_520 VGND VGND VPWR VPWR sky130_fd_sc_hd__decap_3
XFILLER_76_542 VGND VGND VPWR VPWR sky130_fd_sc_hd__decap_3
XFILLER_63_203 VGND VGND VPWR VPWR sky130_fd_sc_hd__decap_3
XFILLER_76_575 VGND VGND VPWR VPWR sky130_fd_sc_hd__decap_3
XFILLER_17_620 VGND VGND VPWR VPWR sky130_fd_sc_hd__decap_3
XFILLER_29_480 VGND VGND VPWR VPWR sky130_fd_sc_hd__decap_3
XFILLER_76_597 VGND VGND VPWR VPWR sky130_fd_sc_hd__decap_3
XFILLER_91_523 VGND VGND VPWR VPWR sky130_fd_sc_hd__fill_2
XTAP_TAPCELL_ROW_106_1521 VGND VPWR sky130_fd_sc_hd__tapvpwrvgnd_1
XFILLER_16_141 VGND VGND VPWR VPWR sky130_fd_sc_hd__decap_3
XFILLER_44_450 VGND VGND VPWR VPWR sky130_fd_sc_hd__fill_2
XFILLER_91_567 VGND VGND VPWR VPWR sky130_fd_sc_hd__decap_3
XFILLER_31_100 VGND VGND VPWR VPWR sky130_fd_sc_hd__decap_3
Xplace269 _3869_/B1 VGND VGND VPWR VPWR _3925_/B1 sky130_fd_sc_hd__buf_2
XFILLER_31_122 VGND VGND VPWR VPWR sky130_fd_sc_hd__decap_3
XFILLER_32_645 VGND VGND VPWR VPWR sky130_fd_sc_hd__fill_1
XFILLER_31_155 VGND VGND VPWR VPWR sky130_fd_sc_hd__decap_3
XFILLER_32_678 VGND VGND VPWR VPWR sky130_fd_sc_hd__decap_3
XFILLER_72_81 VGND VGND VPWR VPWR sky130_fd_sc_hd__decap_3
X_3790_ _3746_/X _3777_/X _3779_/X _3923_/A1 _3789_/X VGND VGND VPWR VPWR _3790_/X
+ sky130_fd_sc_hd__a221o_2
XFILLER_12_391 VGND VGND VPWR VPWR sky130_fd_sc_hd__decap_3
XFILLER_31_199 VGND VGND VPWR VPWR sky130_fd_sc_hd__decap_3
XFILLER_8_362 VGND VGND VPWR VPWR sky130_fd_sc_hd__fill_2
X_4411_ _4411_/A _4411_/B VGND VGND VPWR VPWR _4412_/B sky130_fd_sc_hd__and2_2
XFILLER_113_422 VGND VGND VPWR VPWR sky130_fd_sc_hd__decap_3
X_7130_ _7279_/CLK _7130_/D _6410_/Y VGND VGND VPWR VPWR _7130_/Q sky130_fd_sc_hd__dfrtp_2
X_4342_ _7063_/Q _4305_/B _4460_/A VGND VGND VPWR VPWR _4365_/B sky130_fd_sc_hd__o21a_2
XFILLER_99_634 VGND VGND VPWR VPWR sky130_fd_sc_hd__fill_1
XFILLER_98_111 VGND VGND VPWR VPWR sky130_fd_sc_hd__decap_3
XFILLER_101_606 VGND VGND VPWR VPWR sky130_fd_sc_hd__decap_3
X_7061_ clkload8/A _7061_/D _6341_/Y VGND VGND VPWR VPWR _7061_/Q sky130_fd_sc_hd__dfrtp_2
X_4273_ _4376_/A _4376_/B _4376_/C _4273_/D VGND VGND VPWR VPWR _4273_/Y sky130_fd_sc_hd__nor4_1
XFILLER_99_656 VGND VGND VPWR VPWR sky130_fd_sc_hd__decap_3
XFILLER_101_617 VGND VGND VPWR VPWR sky130_fd_sc_hd__decap_3
XFILLER_39_200 VGND VGND VPWR VPWR sky130_fd_sc_hd__decap_3
.ends
