* NGSPICE file created from single_cycle_cpu.ext - technology: sky130A

* Black-box entry subcircuit for sky130_fd_sc_hd__decap_3 abstract view
.subckt sky130_fd_sc_hd__decap_3 VGND VNB VPB VPWR
.ends

* Black-box entry subcircuit for sky130_fd_sc_hd__dfxtp_2 abstract view
.subckt sky130_fd_sc_hd__dfxtp_2 CLK D VGND VNB VPB VPWR Q
.ends

* Black-box entry subcircuit for sky130_fd_sc_hd__fill_1 abstract view
.subckt sky130_fd_sc_hd__fill_1 VGND VNB VPB VPWR
.ends

* Black-box entry subcircuit for sky130_fd_sc_hd__fill_2 abstract view
.subckt sky130_fd_sc_hd__fill_2 VGND VNB VPB VPWR
.ends

* Black-box entry subcircuit for sky130_fd_sc_hd__tapvpwrvgnd_1 abstract view
.subckt sky130_fd_sc_hd__tapvpwrvgnd_1 VGND VPWR
.ends

* Black-box entry subcircuit for sky130_fd_sc_hd__mux2_2 abstract view
.subckt sky130_fd_sc_hd__mux2_2 A0 A1 S VGND VNB VPB VPWR X
.ends

* Black-box entry subcircuit for sky130_fd_sc_hd__nor4_2 abstract view
.subckt sky130_fd_sc_hd__nor4_2 A B C D VGND VNB VPB VPWR Y
.ends

* Black-box entry subcircuit for sky130_fd_sc_hd__or2_2 abstract view
.subckt sky130_fd_sc_hd__or2_2 A B VGND VNB VPB VPWR X
.ends

* Black-box entry subcircuit for sky130_fd_sc_hd__dfrtp_2 abstract view
.subckt sky130_fd_sc_hd__dfrtp_2 CLK D RESET_B VGND VNB VPB VPWR Q
.ends

* Black-box entry subcircuit for sky130_fd_sc_hd__dlygate4sd3_1 abstract view
.subckt sky130_fd_sc_hd__dlygate4sd3_1 A VGND VNB VPB VPWR X
.ends

* Black-box entry subcircuit for sky130_fd_sc_hd__nor3_2 abstract view
.subckt sky130_fd_sc_hd__nor3_2 A B C VGND VNB VPB VPWR Y
.ends

* Black-box entry subcircuit for sky130_fd_sc_hd__a221o_2 abstract view
.subckt sky130_fd_sc_hd__a221o_2 A1 A2 B1 B2 C1 VGND VNB VPB VPWR X
.ends

* Black-box entry subcircuit for sky130_fd_sc_hd__inv_2 abstract view
.subckt sky130_fd_sc_hd__inv_2 A VGND VNB VPB VPWR Y
.ends

* Black-box entry subcircuit for sky130_fd_sc_hd__a22o_2 abstract view
.subckt sky130_fd_sc_hd__a22o_2 A1 A2 B1 B2 VGND VNB VPB VPWR X
.ends

* Black-box entry subcircuit for sky130_fd_sc_hd__clkdlybuf4s25_1 abstract view
.subckt sky130_fd_sc_hd__clkdlybuf4s25_1 A VGND VNB VPB VPWR X
.ends

* Black-box entry subcircuit for sky130_fd_sc_hd__a211o_2 abstract view
.subckt sky130_fd_sc_hd__a211o_2 A1 A2 B1 C1 VGND VNB VPB VPWR X
.ends

* Black-box entry subcircuit for sky130_fd_sc_hd__and3_4 abstract view
.subckt sky130_fd_sc_hd__and3_4 A B C VGND VNB VPB VPWR X
.ends

* Black-box entry subcircuit for sky130_fd_sc_hd__a31o_2 abstract view
.subckt sky130_fd_sc_hd__a31o_2 A1 A2 A3 B1 VGND VNB VPB VPWR X
.ends

* Black-box entry subcircuit for sky130_fd_sc_hd__or4_4 abstract view
.subckt sky130_fd_sc_hd__or4_4 A B C D VGND VNB VPB VPWR X
.ends

* Black-box entry subcircuit for sky130_fd_sc_hd__nor2_2 abstract view
.subckt sky130_fd_sc_hd__nor2_2 A B VGND VNB VPB VPWR Y
.ends

* Black-box entry subcircuit for sky130_fd_sc_hd__o31a_2 abstract view
.subckt sky130_fd_sc_hd__o31a_2 A1 A2 A3 B1 VGND VNB VPB VPWR X
.ends

* Black-box entry subcircuit for sky130_fd_sc_hd__or3b_4 abstract view
.subckt sky130_fd_sc_hd__or3b_4 A B C_N VGND VNB VPB VPWR X
.ends

* Black-box entry subcircuit for sky130_fd_sc_hd__and2_2 abstract view
.subckt sky130_fd_sc_hd__and2_2 A B VGND VNB VPB VPWR X
.ends

* Black-box entry subcircuit for sky130_fd_sc_hd__xnor2_2 abstract view
.subckt sky130_fd_sc_hd__xnor2_2 A B VGND VNB VPB VPWR Y
.ends

* Black-box entry subcircuit for sky130_fd_sc_hd__o21ai_2 abstract view
.subckt sky130_fd_sc_hd__o21ai_2 A1 A2 B1 VGND VNB VPB VPWR Y
.ends

* Black-box entry subcircuit for sky130_fd_sc_hd__nand2_2 abstract view
.subckt sky130_fd_sc_hd__nand2_2 A B VGND VNB VPB VPWR Y
.ends

* Black-box entry subcircuit for sky130_fd_sc_hd__and3_2 abstract view
.subckt sky130_fd_sc_hd__and3_2 A B C VGND VNB VPB VPWR X
.ends

* Black-box entry subcircuit for sky130_fd_sc_hd__and2b_2 abstract view
.subckt sky130_fd_sc_hd__and2b_2 A_N B VGND VNB VPB VPWR X
.ends

* Black-box entry subcircuit for sky130_fd_sc_hd__a21o_2 abstract view
.subckt sky130_fd_sc_hd__a21o_2 A1 A2 B1 VGND VNB VPB VPWR X
.ends

* Black-box entry subcircuit for sky130_fd_sc_hd__or3_2 abstract view
.subckt sky130_fd_sc_hd__or3_2 A B C VGND VNB VPB VPWR X
.ends

* Black-box entry subcircuit for sky130_fd_sc_hd__buf_2 abstract view
.subckt sky130_fd_sc_hd__buf_2 A VGND VNB VPB VPWR X
.ends

* Black-box entry subcircuit for sky130_fd_sc_hd__diode_2 abstract view
.subckt sky130_fd_sc_hd__diode_2 DIODE VGND VNB VPB VPWR
.ends

* Black-box entry subcircuit for sky130_fd_sc_hd__a31oi_4 abstract view
.subckt sky130_fd_sc_hd__a31oi_4 A1 A2 A3 B1 VGND VNB VPB VPWR Y
.ends

* Black-box entry subcircuit for sky130_fd_sc_hd__o21a_2 abstract view
.subckt sky130_fd_sc_hd__o21a_2 A1 A2 B1 VGND VNB VPB VPWR X
.ends

* Black-box entry subcircuit for sky130_fd_sc_hd__o32a_2 abstract view
.subckt sky130_fd_sc_hd__o32a_2 A1 A2 A3 B1 B2 VGND VNB VPB VPWR X
.ends

* Black-box entry subcircuit for sky130_fd_sc_hd__or3b_2 abstract view
.subckt sky130_fd_sc_hd__or3b_2 A B C_N VGND VNB VPB VPWR X
.ends

* Black-box entry subcircuit for sky130_fd_sc_hd__clkbuf_16 abstract view
.subckt sky130_fd_sc_hd__clkbuf_16 A VGND VNB VPB VPWR X
.ends

* Black-box entry subcircuit for sky130_fd_sc_hd__o211ai_2 abstract view
.subckt sky130_fd_sc_hd__o211ai_2 A1 A2 B1 C1 VGND VNB VPB VPWR Y
.ends

* Black-box entry subcircuit for sky130_fd_sc_hd__o22a_2 abstract view
.subckt sky130_fd_sc_hd__o22a_2 A1 A2 B1 B2 VGND VNB VPB VPWR X
.ends

* Black-box entry subcircuit for sky130_fd_sc_hd__o221a_2 abstract view
.subckt sky130_fd_sc_hd__o221a_2 A1 A2 B1 B2 C1 VGND VNB VPB VPWR X
.ends

* Black-box entry subcircuit for sky130_fd_sc_hd__o311a_4 abstract view
.subckt sky130_fd_sc_hd__o311a_4 A1 A2 A3 B1 C1 VGND VNB VPB VPWR X
.ends

* Black-box entry subcircuit for sky130_fd_sc_hd__a211oi_4 abstract view
.subckt sky130_fd_sc_hd__a211oi_4 A1 A2 B1 C1 VGND VNB VPB VPWR Y
.ends

* Black-box entry subcircuit for sky130_fd_sc_hd__xor2_2 abstract view
.subckt sky130_fd_sc_hd__xor2_2 A B VGND VNB VPB VPWR X
.ends

* Black-box entry subcircuit for sky130_fd_sc_hd__or4b_2 abstract view
.subckt sky130_fd_sc_hd__or4b_2 A B C D_N VGND VNB VPB VPWR X
.ends

* Black-box entry subcircuit for sky130_fd_sc_hd__o2bb2a_2 abstract view
.subckt sky130_fd_sc_hd__o2bb2a_2 A1_N A2_N B1 B2 VGND VNB VPB VPWR X
.ends

* Black-box entry subcircuit for sky130_fd_sc_hd__nand3_1 abstract view
.subckt sky130_fd_sc_hd__nand3_1 A B C VGND VNB VPB VPWR Y
.ends

* Black-box entry subcircuit for sky130_fd_sc_hd__o31ai_4 abstract view
.subckt sky130_fd_sc_hd__o31ai_4 A1 A2 A3 B1 VGND VNB VPB VPWR Y
.ends

* Black-box entry subcircuit for sky130_fd_sc_hd__o21ba_2 abstract view
.subckt sky130_fd_sc_hd__o21ba_2 A1 A2 B1_N VGND VNB VPB VPWR X
.ends

* Black-box entry subcircuit for sky130_fd_sc_hd__or2_4 abstract view
.subckt sky130_fd_sc_hd__or2_4 A B VGND VNB VPB VPWR X
.ends

* Black-box entry subcircuit for sky130_fd_sc_hd__a211oi_2 abstract view
.subckt sky130_fd_sc_hd__a211oi_2 A1 A2 B1 C1 VGND VNB VPB VPWR Y
.ends

* Black-box entry subcircuit for sky130_fd_sc_hd__a21bo_2 abstract view
.subckt sky130_fd_sc_hd__a21bo_2 A1 A2 B1_N VGND VNB VPB VPWR X
.ends

* Black-box entry subcircuit for sky130_fd_sc_hd__a31oi_2 abstract view
.subckt sky130_fd_sc_hd__a31oi_2 A1 A2 A3 B1 VGND VNB VPB VPWR Y
.ends

* Black-box entry subcircuit for sky130_fd_sc_hd__a21oi_2 abstract view
.subckt sky130_fd_sc_hd__a21oi_2 A1 A2 B1 VGND VNB VPB VPWR Y
.ends

* Black-box entry subcircuit for sky130_fd_sc_hd__o211a_2 abstract view
.subckt sky130_fd_sc_hd__o211a_2 A1 A2 B1 C1 VGND VNB VPB VPWR X
.ends

* Black-box entry subcircuit for sky130_fd_sc_hd__or2b_2 abstract view
.subckt sky130_fd_sc_hd__or2b_2 A B_N VGND VNB VPB VPWR X
.ends

* Black-box entry subcircuit for sky130_fd_sc_hd__a32o_2 abstract view
.subckt sky130_fd_sc_hd__a32o_2 A1 A2 A3 B1 B2 VGND VNB VPB VPWR X
.ends

* Black-box entry subcircuit for sky130_fd_sc_hd__a2bb2o_2 abstract view
.subckt sky130_fd_sc_hd__a2bb2o_2 A1_N A2_N B1 B2 VGND VNB VPB VPWR X
.ends

* Black-box entry subcircuit for sky130_fd_sc_hd__xor2_4 abstract view
.subckt sky130_fd_sc_hd__xor2_4 A B VGND VNB VPB VPWR X
.ends

* Black-box entry subcircuit for sky130_fd_sc_hd__buf_1 abstract view
.subckt sky130_fd_sc_hd__buf_1 A VGND VNB VPB VPWR X
.ends

* Black-box entry subcircuit for sky130_fd_sc_hd__a21boi_2 abstract view
.subckt sky130_fd_sc_hd__a21boi_2 A1 A2 B1_N VGND VNB VPB VPWR Y
.ends

* Black-box entry subcircuit for sky130_fd_sc_hd__and2_4 abstract view
.subckt sky130_fd_sc_hd__and2_4 A B VGND VNB VPB VPWR X
.ends

* Black-box entry subcircuit for sky130_fd_sc_hd__o2111a_2 abstract view
.subckt sky130_fd_sc_hd__o2111a_2 A1 A2 B1 C1 D1 VGND VNB VPB VPWR X
.ends

* Black-box entry subcircuit for sky130_fd_sc_hd__clkbuf_1 abstract view
.subckt sky130_fd_sc_hd__clkbuf_1 A VGND VNB VPB VPWR X
.ends

* Black-box entry subcircuit for sky130_fd_sc_hd__and4_4 abstract view
.subckt sky130_fd_sc_hd__and4_4 A B C D VGND VNB VPB VPWR X
.ends

* Black-box entry subcircuit for sky130_fd_sc_hd__o31ai_2 abstract view
.subckt sky130_fd_sc_hd__o31ai_2 A1 A2 A3 B1 VGND VNB VPB VPWR Y
.ends

* Black-box entry subcircuit for sky130_fd_sc_hd__o311a_2 abstract view
.subckt sky130_fd_sc_hd__o311a_2 A1 A2 A3 B1 C1 VGND VNB VPB VPWR X
.ends

* Black-box entry subcircuit for sky130_fd_sc_hd__clkbuf_8 abstract view
.subckt sky130_fd_sc_hd__clkbuf_8 A VGND VNB VPB VPWR X
.ends

* Black-box entry subcircuit for sky130_fd_sc_hd__a31o_4 abstract view
.subckt sky130_fd_sc_hd__a31o_4 A1 A2 A3 B1 VGND VNB VPB VPWR X
.ends

* Black-box entry subcircuit for sky130_fd_sc_hd__bufinv_16 abstract view
.subckt sky130_fd_sc_hd__bufinv_16 A VGND VNB VPB VPWR Y
.ends

* Black-box entry subcircuit for sky130_fd_sc_hd__clkinv_4 abstract view
.subckt sky130_fd_sc_hd__clkinv_4 A VGND VNB VPB VPWR Y
.ends

* Black-box entry subcircuit for sky130_fd_sc_hd__inv_4 abstract view
.subckt sky130_fd_sc_hd__inv_4 A VGND VNB VPB VPWR Y
.ends

* Black-box entry subcircuit for sky130_fd_sc_hd__nor2_4 abstract view
.subckt sky130_fd_sc_hd__nor2_4 A B VGND VNB VPB VPWR Y
.ends

* Black-box entry subcircuit for sky130_fd_sc_hd__inv_6 abstract view
.subckt sky130_fd_sc_hd__inv_6 A VGND VNB VPB VPWR Y
.ends

* Black-box entry subcircuit for sky130_fd_sc_hd__a221oi_2 abstract view
.subckt sky130_fd_sc_hd__a221oi_2 A1 A2 B1 B2 C1 VGND VNB VPB VPWR Y
.ends

* Black-box entry subcircuit for sky130_fd_sc_hd__and3b_2 abstract view
.subckt sky130_fd_sc_hd__and3b_2 A_N B C VGND VNB VPB VPWR X
.ends

* Black-box entry subcircuit for sky130_fd_sc_hd__nand3b_2 abstract view
.subckt sky130_fd_sc_hd__nand3b_2 A_N B C VGND VNB VPB VPWR Y
.ends

* Black-box entry subcircuit for sky130_fd_sc_hd__clkbuf_2 abstract view
.subckt sky130_fd_sc_hd__clkbuf_2 A VGND VNB VPB VPWR X
.ends

* Black-box entry subcircuit for sky130_fd_sc_hd__clkinv_2 abstract view
.subckt sky130_fd_sc_hd__clkinv_2 A VGND VNB VPB VPWR Y
.ends

* Black-box entry subcircuit for sky130_fd_sc_hd__or3_4 abstract view
.subckt sky130_fd_sc_hd__or3_4 A B C VGND VNB VPB VPWR X
.ends

* Black-box entry subcircuit for sky130_fd_sc_hd__nor4b_2 abstract view
.subckt sky130_fd_sc_hd__nor4b_2 A B C D_N VGND VNB VPB VPWR Y
.ends

* Black-box entry subcircuit for sky130_fd_sc_hd__nand3_2 abstract view
.subckt sky130_fd_sc_hd__nand3_2 A B C VGND VNB VPB VPWR Y
.ends

* Black-box entry subcircuit for sky130_fd_sc_hd__a21oi_4 abstract view
.subckt sky130_fd_sc_hd__a21oi_4 A1 A2 B1 VGND VNB VPB VPWR Y
.ends

* Black-box entry subcircuit for sky130_fd_sc_hd__o221ai_2 abstract view
.subckt sky130_fd_sc_hd__o221ai_2 A1 A2 B1 B2 C1 VGND VNB VPB VPWR Y
.ends

* Black-box entry subcircuit for sky130_fd_sc_hd__nand2b_4 abstract view
.subckt sky130_fd_sc_hd__nand2b_4 A_N B VGND VNB VPB VPWR Y
.ends

* Black-box entry subcircuit for sky130_fd_sc_hd__a2111o_2 abstract view
.subckt sky130_fd_sc_hd__a2111o_2 A1 A2 B1 C1 D1 VGND VNB VPB VPWR X
.ends

* Black-box entry subcircuit for sky130_fd_sc_hd__mux4_2 abstract view
.subckt sky130_fd_sc_hd__mux4_2 A0 A1 A2 A3 S0 S1 VGND VNB VPB VPWR X
.ends

* Black-box entry subcircuit for sky130_fd_sc_hd__dfstp_2 abstract view
.subckt sky130_fd_sc_hd__dfstp_2 CLK D SET_B VGND VNB VPB VPWR Q
.ends

* Black-box entry subcircuit for sky130_fd_sc_hd__nor2b_2 abstract view
.subckt sky130_fd_sc_hd__nor2b_2 A B_N VGND VNB VPB VPWR Y
.ends

* Black-box entry subcircuit for sky130_fd_sc_hd__or4_2 abstract view
.subckt sky130_fd_sc_hd__or4_2 A B C D VGND VNB VPB VPWR X
.ends

* Black-box entry subcircuit for sky130_fd_sc_hd__clkinv_8 abstract view
.subckt sky130_fd_sc_hd__clkinv_8 A VGND VNB VPB VPWR Y
.ends

* Black-box entry subcircuit for sky130_fd_sc_hd__and4_2 abstract view
.subckt sky130_fd_sc_hd__and4_2 A B C D VGND VNB VPB VPWR X
.ends

* Black-box entry subcircuit for sky130_fd_sc_hd__a311oi_2 abstract view
.subckt sky130_fd_sc_hd__a311oi_2 A1 A2 A3 B1 C1 VGND VNB VPB VPWR Y
.ends

* Black-box entry subcircuit for sky130_fd_sc_hd__buf_4 abstract view
.subckt sky130_fd_sc_hd__buf_4 A VGND VNB VPB VPWR X
.ends

* Black-box entry subcircuit for sky130_fd_sc_hd__o21a_4 abstract view
.subckt sky130_fd_sc_hd__o21a_4 A1 A2 B1 VGND VNB VPB VPWR X
.ends

* Black-box entry subcircuit for sky130_fd_sc_hd__a41o_2 abstract view
.subckt sky130_fd_sc_hd__a41o_2 A1 A2 A3 A4 B1 VGND VNB VPB VPWR X
.ends

* Black-box entry subcircuit for sky130_fd_sc_hd__nand4bb_2 abstract view
.subckt sky130_fd_sc_hd__nand4bb_2 A_N B_N C D VGND VNB VPB VPWR Y
.ends

* Black-box entry subcircuit for sky130_fd_sc_hd__o21bai_2 abstract view
.subckt sky130_fd_sc_hd__o21bai_2 A1 A2 B1_N VGND VNB VPB VPWR Y
.ends

* Black-box entry subcircuit for sky130_fd_sc_hd__nand2_4 abstract view
.subckt sky130_fd_sc_hd__nand2_4 A B VGND VNB VPB VPWR Y
.ends

* Black-box entry subcircuit for sky130_fd_sc_hd__mux2_4 abstract view
.subckt sky130_fd_sc_hd__mux2_4 A0 A1 S VGND VNB VPB VPWR X
.ends

* Black-box entry subcircuit for sky130_fd_sc_hd__o211ai_4 abstract view
.subckt sky130_fd_sc_hd__o211ai_4 A1 A2 B1 C1 VGND VNB VPB VPWR Y
.ends

* Black-box entry subcircuit for sky130_fd_sc_hd__and4bb_4 abstract view
.subckt sky130_fd_sc_hd__and4bb_4 A_N B_N C D VGND VNB VPB VPWR X
.ends

* Black-box entry subcircuit for sky130_fd_sc_hd__o21ai_4 abstract view
.subckt sky130_fd_sc_hd__o21ai_4 A1 A2 B1 VGND VNB VPB VPWR Y
.ends

* Black-box entry subcircuit for sky130_fd_sc_hd__nand2b_2 abstract view
.subckt sky130_fd_sc_hd__nand2b_2 A_N B VGND VNB VPB VPWR Y
.ends

* Black-box entry subcircuit for sky130_fd_sc_hd__o211a_4 abstract view
.subckt sky130_fd_sc_hd__o211a_4 A1 A2 B1 C1 VGND VNB VPB VPWR X
.ends

* Black-box entry subcircuit for sky130_fd_sc_hd__or4b_4 abstract view
.subckt sky130_fd_sc_hd__or4b_4 A B C D_N VGND VNB VPB VPWR X
.ends

* Black-box entry subcircuit for sky130_fd_sc_hd__nor4bb_2 abstract view
.subckt sky130_fd_sc_hd__nor4bb_2 A B C_N D_N VGND VNB VPB VPWR Y
.ends

* Black-box entry subcircuit for sky130_fd_sc_hd__and4b_4 abstract view
.subckt sky130_fd_sc_hd__and4b_4 A_N B C D VGND VNB VPB VPWR X
.ends

* Black-box entry subcircuit for sky130_fd_sc_hd__clkbuf_4 abstract view
.subckt sky130_fd_sc_hd__clkbuf_4 A VGND VNB VPB VPWR X
.ends

* Black-box entry subcircuit for sky130_fd_sc_hd__conb_1 abstract view
.subckt sky130_fd_sc_hd__conb_1 VGND VNB VPB VPWR HI LO
.ends

* Black-box entry subcircuit for sky130_fd_sc_hd__nor3b_2 abstract view
.subckt sky130_fd_sc_hd__nor3b_2 A B C_N VGND VNB VPB VPWR Y
.ends

* Black-box entry subcircuit for sky130_fd_sc_hd__a22oi_2 abstract view
.subckt sky130_fd_sc_hd__a22oi_2 A1 A2 B1 B2 VGND VNB VPB VPWR Y
.ends

* Black-box entry subcircuit for sky130_fd_sc_hd__a311o_2 abstract view
.subckt sky130_fd_sc_hd__a311o_2 A1 A2 A3 B1 C1 VGND VNB VPB VPWR X
.ends

* Black-box entry subcircuit for sky130_fd_sc_hd__nand4b_4 abstract view
.subckt sky130_fd_sc_hd__nand4b_4 A_N B C D VGND VNB VPB VPWR Y
.ends

* Black-box entry subcircuit for sky130_fd_sc_hd__a2bb2o_4 abstract view
.subckt sky130_fd_sc_hd__a2bb2o_4 A1_N A2_N B1 B2 VGND VNB VPB VPWR X
.ends

* Black-box entry subcircuit for sky130_fd_sc_hd__nor4_1 abstract view
.subckt sky130_fd_sc_hd__nor4_1 A B C D VGND VNB VPB VPWR Y
.ends

.subckt single_cycle_cpu VGND VPWR alu_result_out[0] alu_result_out[10] alu_result_out[11]
+ alu_result_out[12] alu_result_out[13] alu_result_out[14] alu_result_out[15] alu_result_out[16]
+ alu_result_out[17] alu_result_out[18] alu_result_out[19] alu_result_out[1] alu_result_out[20]
+ alu_result_out[21] alu_result_out[22] alu_result_out[23] alu_result_out[24] alu_result_out[25]
+ alu_result_out[26] alu_result_out[27] alu_result_out[28] alu_result_out[29] alu_result_out[2]
+ alu_result_out[30] alu_result_out[31] alu_result_out[3] alu_result_out[4] alu_result_out[5]
+ alu_result_out[6] alu_result_out[7] alu_result_out[8] alu_result_out[9] clk instruction_out[0]
+ instruction_out[10] instruction_out[11] instruction_out[12] instruction_out[13]
+ instruction_out[14] instruction_out[15] instruction_out[16] instruction_out[17]
+ instruction_out[18] instruction_out[19] instruction_out[1] instruction_out[20] instruction_out[21]
+ instruction_out[22] instruction_out[23] instruction_out[24] instruction_out[25]
+ instruction_out[26] instruction_out[27] instruction_out[28] instruction_out[29]
+ instruction_out[2] instruction_out[30] instruction_out[31] instruction_out[3] instruction_out[4]
+ instruction_out[5] instruction_out[6] instruction_out[7] instruction_out[8] instruction_out[9]
+ pc_out[0] pc_out[10] pc_out[11] pc_out[12] pc_out[13] pc_out[14] pc_out[15] pc_out[16]
+ pc_out[17] pc_out[18] pc_out[19] pc_out[1] pc_out[20] pc_out[21] pc_out[22] pc_out[23]
+ pc_out[24] pc_out[25] pc_out[26] pc_out[27] pc_out[28] pc_out[29] pc_out[2] pc_out[30]
+ pc_out[31] pc_out[3] pc_out[4] pc_out[5] pc_out[6] pc_out[7] pc_out[8] pc_out[9]
+ reset
XFILLER_39_244 VGND VGND VPWR VPWR sky130_fd_sc_hd__decap_3
XFILLER_67_520 VGND VGND VPWR VPWR sky130_fd_sc_hd__decap_3
XFILLER_67_553 VGND VGND VPWR VPWR sky130_fd_sc_hd__decap_3
XFILLER_39_266 VGND VGND VPWR VPWR sky130_fd_sc_hd__decap_3
XFILLER_54_203 VGND VGND VPWR VPWR sky130_fd_sc_hd__decap_3
XFILLER_94_361 VGND VGND VPWR VPWR sky130_fd_sc_hd__decap_3
XFILLER_27_439 VGND VGND VPWR VPWR sky130_fd_sc_hd__decap_3
XFILLER_54_236 VGND VGND VPWR VPWR sky130_fd_sc_hd__decap_3
XFILLER_67_597 VGND VGND VPWR VPWR sky130_fd_sc_hd__decap_3
XFILLER_82_556 VGND VGND VPWR VPWR sky130_fd_sc_hd__decap_3
X_6914_ _7383_/CLK _6914_/D VGND VGND VPWR VPWR _6914_/Q sky130_fd_sc_hd__dfxtp_2
XFILLER_22_100 VGND VGND VPWR VPWR sky130_fd_sc_hd__decap_3
XFILLER_35_483 VGND VGND VPWR VPWR sky130_fd_sc_hd__fill_1
XFILLER_82_589 VGND VGND VPWR VPWR sky130_fd_sc_hd__decap_3
XFILLER_23_645 VGND VGND VPWR VPWR sky130_fd_sc_hd__fill_2
XFILLER_35_494 VGND VGND VPWR VPWR sky130_fd_sc_hd__fill_2
XFILLER_52_18 VGND VGND VPWR VPWR sky130_fd_sc_hd__decap_3
XFILLER_52_29 VGND VGND VPWR VPWR sky130_fd_sc_hd__decap_3
X_6845_ _7351_/CLK _6845_/D VGND VGND VPWR VPWR _6845_/Q sky130_fd_sc_hd__dfxtp_2
XTAP_TAPCELL_ROW_81_1226 VGND VPWR sky130_fd_sc_hd__tapvpwrvgnd_1
XFILLER_22_144 VGND VGND VPWR VPWR sky130_fd_sc_hd__decap_3
X_6776_ _6965_/CLK _6776_/D VGND VGND VPWR VPWR _6776_/Q sky130_fd_sc_hd__dfxtp_2
XTAP_TAPCELL_ROW_61_982 VGND VPWR sky130_fd_sc_hd__tapvpwrvgnd_1
XTAP_TAPCELL_ROW_33_651 VGND VPWR sky130_fd_sc_hd__tapvpwrvgnd_1
XFILLER_10_339 VGND VGND VPWR VPWR sky130_fd_sc_hd__decap_3
X_5727_ _7369_/Q hold915/X _5737_/S VGND VGND VPWR VPWR _6713_/D sky130_fd_sc_hd__mux2_2
XFILLER_108_205 VGND VGND VPWR VPWR sky130_fd_sc_hd__decap_3
X_5658_ _5658_/A _5658_/B _5658_/C _5658_/D VGND VGND VPWR VPWR _5661_/C sky130_fd_sc_hd__nor4_2
XPHY_EDGE_ROW_107_Left_224 VGND VGND VPWR VPWR sky130_fd_sc_hd__decap_3
X_5589_ _5589_/A _5595_/B VGND VGND VPWR VPWR _7033_/D sky130_fd_sc_hd__or2_2
XTAP_TAPCELL_ROW_79_1199 VGND VPWR sky130_fd_sc_hd__tapvpwrvgnd_1
XFILLER_104_400 VGND VGND VPWR VPWR sky130_fd_sc_hd__decap_3
XFILLER_116_271 VGND VGND VPWR VPWR sky130_fd_sc_hd__fill_1
XFILLER_2_516 VGND VGND VPWR VPWR sky130_fd_sc_hd__decap_3
XFILLER_89_111 VGND VGND VPWR VPWR sky130_fd_sc_hd__fill_1
XFILLER_89_122 VGND VGND VPWR VPWR sky130_fd_sc_hd__decap_3
X_7328_ _7396_/CLK _7328_/D _6608_/Y VGND VGND VPWR VPWR _7328_/Q sky130_fd_sc_hd__dfrtp_2
XFILLER_104_433 VGND VGND VPWR VPWR sky130_fd_sc_hd__decap_3
XFILLER_77_15 VGND VGND VPWR VPWR sky130_fd_sc_hd__decap_3
XFILLER_77_37 VGND VGND VPWR VPWR sky130_fd_sc_hd__decap_3
XFILLER_89_133 VGND VGND VPWR VPWR sky130_fd_sc_hd__decap_3
X_7259_ clkload9/A _7259_/D _6539_/Y VGND VGND VPWR VPWR _7259_/Q sky130_fd_sc_hd__dfrtp_2
XTAP_TAPCELL_ROW_92_1355 VGND VPWR sky130_fd_sc_hd__tapvpwrvgnd_1
XFILLER_104_477 VGND VGND VPWR VPWR sky130_fd_sc_hd__decap_3
XFILLER_77_328 VGND VGND VPWR VPWR sky130_fd_sc_hd__decap_3
XTAP_TAPCELL_ROW_5_310 VGND VPWR sky130_fd_sc_hd__tapvpwrvgnd_1
XFILLER_58_531 VGND VGND VPWR VPWR sky130_fd_sc_hd__fill_1
XFILLER_58_542 VGND VGND VPWR VPWR sky130_fd_sc_hd__decap_3
XFILLER_85_361 VGND VGND VPWR VPWR sky130_fd_sc_hd__decap_3
XFILLER_92_309 VGND VGND VPWR VPWR sky130_fd_sc_hd__decap_3
Xhold1040 _7200_/Q VGND VGND VPWR VPWR _5260_/A0 sky130_fd_sc_hd__dlygate4sd3_1
Xhold1051 _7241_/Q VGND VGND VPWR VPWR _5173_/A sky130_fd_sc_hd__dlygate4sd3_1
XFILLER_45_203 VGND VGND VPWR VPWR sky130_fd_sc_hd__decap_3
XFILLER_73_523 VGND VGND VPWR VPWR sky130_fd_sc_hd__decap_3
XFILLER_85_383 VGND VGND VPWR VPWR sky130_fd_sc_hd__decap_3
Xhold1062 _7232_/Q VGND VGND VPWR VPWR _5192_/A sky130_fd_sc_hd__dlygate4sd3_1
Xhold1073 _7327_/Q VGND VGND VPWR VPWR _4505_/A0 sky130_fd_sc_hd__dlygate4sd3_1
Xhold1084 _7011_/Q VGND VGND VPWR VPWR _5634_/A sky130_fd_sc_hd__dlygate4sd3_1
XPHY_EDGE_ROW_116_Left_233 VGND VGND VPWR VPWR sky130_fd_sc_hd__decap_3
XFILLER_73_578 VGND VGND VPWR VPWR sky130_fd_sc_hd__decap_3
Xhold1095 _7310_/Q VGND VGND VPWR VPWR _4540_/A sky130_fd_sc_hd__dlygate4sd3_1
XFILLER_26_52 VGND VGND VPWR VPWR sky130_fd_sc_hd__decap_3
XFILLER_60_217 VGND VGND VPWR VPWR sky130_fd_sc_hd__decap_3
XFILLER_13_122 VGND VGND VPWR VPWR sky130_fd_sc_hd__fill_1
XFILLER_41_431 VGND VGND VPWR VPWR sky130_fd_sc_hd__decap_3
XFILLER_13_166 VGND VGND VPWR VPWR sky130_fd_sc_hd__fill_2
XFILLER_41_475 VGND VGND VPWR VPWR sky130_fd_sc_hd__decap_3
XFILLER_13_199 VGND VGND VPWR VPWR sky130_fd_sc_hd__decap_3
XTAP_TAPCELL_ROW_101_1462 VGND VPWR sky130_fd_sc_hd__tapvpwrvgnd_1
XFILLER_9_137 VGND VGND VPWR VPWR sky130_fd_sc_hd__decap_3
XTAP_TAPCELL_ROW_11_389 VGND VPWR sky130_fd_sc_hd__tapvpwrvgnd_1
XTAP_TAPCELL_ROW_11_378 VGND VPWR sky130_fd_sc_hd__tapvpwrvgnd_1
XFILLER_54_9 VGND VGND VPWR VPWR sky130_fd_sc_hd__decap_3
XFILLER_5_332 VGND VGND VPWR VPWR sky130_fd_sc_hd__decap_3
XFILLER_5_343 VGND VGND VPWR VPWR sky130_fd_sc_hd__decap_3
XFILLER_107_260 VGND VGND VPWR VPWR sky130_fd_sc_hd__decap_3
XFILLER_5_376 VGND VGND VPWR VPWR sky130_fd_sc_hd__decap_3
XFILLER_3_12 VGND VGND VPWR VPWR sky130_fd_sc_hd__fill_1
XFILLER_68_306 VGND VGND VPWR VPWR sky130_fd_sc_hd__fill_2
XFILLER_96_637 VGND VGND VPWR VPWR sky130_fd_sc_hd__decap_3
XFILLER_110_436 VGND VGND VPWR VPWR sky130_fd_sc_hd__decap_3
XFILLER_3_67 VGND VGND VPWR VPWR sky130_fd_sc_hd__fill_1
XFILLER_95_136 VGND VGND VPWR VPWR sky130_fd_sc_hd__decap_3
XTAP_TAPCELL_ROW_112_1591 VGND VPWR sky130_fd_sc_hd__tapvpwrvgnd_1
XFILLER_110_469 VGND VGND VPWR VPWR sky130_fd_sc_hd__decap_3
XFILLER_67_70 VGND VGND VPWR VPWR sky130_fd_sc_hd__decap_3
XFILLER_83_309 VGND VGND VPWR VPWR sky130_fd_sc_hd__decap_3
XFILLER_95_169 VGND VGND VPWR VPWR sky130_fd_sc_hd__decap_3
XFILLER_76_383 VGND VGND VPWR VPWR sky130_fd_sc_hd__decap_3
XFILLER_24_409 VGND VGND VPWR VPWR sky130_fd_sc_hd__fill_2
XFILLER_36_236 VGND VGND VPWR VPWR sky130_fd_sc_hd__decap_3
XFILLER_64_545 VGND VGND VPWR VPWR sky130_fd_sc_hd__decap_3
XFILLER_51_206 VGND VGND VPWR VPWR sky130_fd_sc_hd__decap_3
XFILLER_51_228 VGND VGND VPWR VPWR sky130_fd_sc_hd__decap_3
XFILLER_83_80 VGND VGND VPWR VPWR sky130_fd_sc_hd__decap_3
XFILLER_91_364 VGND VGND VPWR VPWR sky130_fd_sc_hd__decap_3
X_4960_ _4960_/A _4960_/B _4960_/C VGND VGND VPWR VPWR _4961_/C sky130_fd_sc_hd__nor3_2
XTAP_TAPCELL_ROW_19_478 VGND VPWR sky130_fd_sc_hd__tapvpwrvgnd_1
XFILLER_44_280 VGND VGND VPWR VPWR sky130_fd_sc_hd__decap_3
X_4891_ _4891_/A1 _4126_/A _4889_/Y _4811_/C _4890_/Y VGND VGND VPWR VPWR _4891_/X
+ sky130_fd_sc_hd__a221o_2
X_3911_ _6690_/Q _3925_/A2 _3925_/B1 _6868_/Q _3910_/X VGND VGND VPWR VPWR _3911_/X
+ sky130_fd_sc_hd__a221o_2
XFILLER_32_453 VGND VGND VPWR VPWR sky130_fd_sc_hd__decap_3
XFILLER_32_475 VGND VGND VPWR VPWR sky130_fd_sc_hd__fill_1
X_6630_ _6635_/A VGND VGND VPWR VPWR _6630_/Y sky130_fd_sc_hd__inv_2
X_3842_ _6925_/Q _3852_/A2 _3853_/A2 _6789_/Q VGND VGND VPWR VPWR _3842_/X sky130_fd_sc_hd__a22o_2
X_6561_ _6562_/A VGND VGND VPWR VPWR _6561_/Y sky130_fd_sc_hd__inv_2
XTAP_TAPCELL_ROW_30_610 VGND VPWR sky130_fd_sc_hd__tapvpwrvgnd_1
X_3773_ _6775_/Q _3869_/A2 _3889_/A2 _6763_/Q VGND VGND VPWR VPWR _3773_/X sky130_fd_sc_hd__a22o_2
X_6492_ _6647_/A VGND VGND VPWR VPWR _6492_/Y sky130_fd_sc_hd__inv_2
XFILLER_105_208 VGND VGND VPWR VPWR sky130_fd_sc_hd__decap_3
XFILLER_8_192 VGND VGND VPWR VPWR sky130_fd_sc_hd__decap_3
XFILLER_99_420 VGND VGND VPWR VPWR sky130_fd_sc_hd__decap_3
X_7113_ _7338_/CLK _7113_/D _6393_/Y VGND VGND VPWR VPWR _7113_/Q sky130_fd_sc_hd__dfrtp_2
Xoutput478 _5656_/B VGND VGND VPWR VPWR alu_result_out[21] sky130_fd_sc_hd__clkdlybuf4s25_1
Xoutput467 _5662_/B VGND VGND VPWR VPWR alu_result_out[11] sky130_fd_sc_hd__clkdlybuf4s25_1
X_4325_ _7354_/Q _4270_/B _4323_/X _4324_/X VGND VGND VPWR VPWR _4325_/X sky130_fd_sc_hd__a211o_2
XFILLER_113_274 VGND VGND VPWR VPWR sky130_fd_sc_hd__decap_3
XFILLER_59_317 VGND VGND VPWR VPWR sky130_fd_sc_hd__decap_3
XFILLER_86_103 VGND VGND VPWR VPWR sky130_fd_sc_hd__fill_2
Xoutput489 _5654_/Y VGND VGND VPWR VPWR alu_result_out[31] sky130_fd_sc_hd__clkdlybuf4s25_1
XFILLER_99_497 VGND VGND VPWR VPWR sky130_fd_sc_hd__decap_3
XFILLER_99_464 VGND VGND VPWR VPWR sky130_fd_sc_hd__decap_3
XFILLER_113_296 VGND VGND VPWR VPWR sky130_fd_sc_hd__decap_3
XFILLER_47_18 VGND VGND VPWR VPWR sky130_fd_sc_hd__decap_3
XFILLER_86_136 VGND VGND VPWR VPWR sky130_fd_sc_hd__decap_3
XFILLER_86_147 VGND VGND VPWR VPWR sky130_fd_sc_hd__decap_3
X_7044_ _7396_/CLK _7044_/D _6324_/Y VGND VGND VPWR VPWR _7044_/Q sky130_fd_sc_hd__dfrtp_2
X_4256_ _4626_/B _4626_/C _4256_/C VGND VGND VPWR VPWR _4988_/A sky130_fd_sc_hd__and3_4
XFILLER_67_361 VGND VGND VPWR VPWR sky130_fd_sc_hd__decap_3
XFILLER_74_309 VGND VGND VPWR VPWR sky130_fd_sc_hd__decap_3
X_4187_ _7327_/Q _4414_/B1 _4505_/S _7295_/Q VGND VGND VPWR VPWR _4187_/X sky130_fd_sc_hd__a22o_2
XFILLER_103_24 VGND VGND VPWR VPWR sky130_fd_sc_hd__decap_3
XFILLER_27_225 VGND VGND VPWR VPWR sky130_fd_sc_hd__decap_3
XFILLER_67_372 VGND VGND VPWR VPWR sky130_fd_sc_hd__decap_3
XFILLER_94_180 VGND VGND VPWR VPWR sky130_fd_sc_hd__decap_3
XTAP_TAPCELL_ROW_38_710 VGND VPWR sky130_fd_sc_hd__tapvpwrvgnd_1
XFILLER_103_46 VGND VGND VPWR VPWR sky130_fd_sc_hd__fill_2
XFILLER_103_57 VGND VGND VPWR VPWR sky130_fd_sc_hd__decap_3
XFILLER_42_206 VGND VGND VPWR VPWR sky130_fd_sc_hd__decap_3
XFILLER_70_526 VGND VGND VPWR VPWR sky130_fd_sc_hd__decap_3
XFILLER_70_548 VGND VGND VPWR VPWR sky130_fd_sc_hd__decap_3
XFILLER_82_397 VGND VGND VPWR VPWR sky130_fd_sc_hd__decap_3
XFILLER_11_604 VGND VGND VPWR VPWR sky130_fd_sc_hd__fill_1
XFILLER_50_250 VGND VGND VPWR VPWR sky130_fd_sc_hd__fill_2
X_6828_ _6976_/CLK _6828_/D VGND VGND VPWR VPWR _6828_/Q sky130_fd_sc_hd__dfxtp_2
XFILLER_23_486 VGND VGND VPWR VPWR sky130_fd_sc_hd__decap_3
XFILLER_50_294 VGND VGND VPWR VPWR sky130_fd_sc_hd__decap_3
XFILLER_109_514 VGND VGND VPWR VPWR sky130_fd_sc_hd__decap_3
XFILLER_10_147 VGND VGND VPWR VPWR sky130_fd_sc_hd__decap_3
XFILLER_12_21 VGND VGND VPWR VPWR sky130_fd_sc_hd__decap_3
X_6759_ _6978_/CLK _6759_/D VGND VGND VPWR VPWR _6759_/Q sky130_fd_sc_hd__dfxtp_2
XFILLER_10_169 VGND VGND VPWR VPWR sky130_fd_sc_hd__decap_3
XFILLER_12_32 VGND VGND VPWR VPWR sky130_fd_sc_hd__decap_3
XFILLER_109_558 VGND VGND VPWR VPWR sky130_fd_sc_hd__fill_2
XFILLER_12_65 VGND VGND VPWR VPWR sky130_fd_sc_hd__decap_3
XFILLER_104_274 VGND VGND VPWR VPWR sky130_fd_sc_hd__fill_1
XFILLER_2_368 VGND VGND VPWR VPWR sky130_fd_sc_hd__decap_3
XFILLER_78_604 VGND VGND VPWR VPWR sky130_fd_sc_hd__decap_3
XFILLER_78_637 VGND VGND VPWR VPWR sky130_fd_sc_hd__decap_3
XFILLER_104_296 VGND VGND VPWR VPWR sky130_fd_sc_hd__decap_3
XFILLER_78_648 VGND VGND VPWR VPWR sky130_fd_sc_hd__fill_2
XFILLER_58_350 VGND VGND VPWR VPWR sky130_fd_sc_hd__decap_3
XFILLER_77_169 VGND VGND VPWR VPWR sky130_fd_sc_hd__decap_3
XFILLER_92_106 VGND VGND VPWR VPWR sky130_fd_sc_hd__decap_3
XFILLER_93_629 VGND VGND VPWR VPWR sky130_fd_sc_hd__fill_1
XFILLER_100_480 VGND VGND VPWR VPWR sky130_fd_sc_hd__decap_3
XFILLER_18_203 VGND VGND VPWR VPWR sky130_fd_sc_hd__decap_3
XFILLER_18_247 VGND VGND VPWR VPWR sky130_fd_sc_hd__decap_3
XFILLER_46_545 VGND VGND VPWR VPWR sky130_fd_sc_hd__decap_3
XFILLER_73_331 VGND VGND VPWR VPWR sky130_fd_sc_hd__fill_2
XFILLER_85_191 VGND VGND VPWR VPWR sky130_fd_sc_hd__decap_3
XFILLER_33_228 VGND VGND VPWR VPWR sky130_fd_sc_hd__decap_3
XTAP_TAPCELL_ROW_16_448 VGND VPWR sky130_fd_sc_hd__tapvpwrvgnd_1
XFILLER_41_250 VGND VGND VPWR VPWR sky130_fd_sc_hd__decap_3
XFILLER_53_72 VGND VGND VPWR VPWR sky130_fd_sc_hd__decap_3
XTAP_TAPCELL_ROW_44_779 VGND VPWR sky130_fd_sc_hd__tapvpwrvgnd_1
XFILLER_5_140 VGND VGND VPWR VPWR sky130_fd_sc_hd__decap_3
XFILLER_115_528 VGND VGND VPWR VPWR sky130_fd_sc_hd__decap_3
XTAP_TAPCELL_ROW_114_1620 VGND VPWR sky130_fd_sc_hd__tapvpwrvgnd_1
XFILLER_5_184 VGND VGND VPWR VPWR sky130_fd_sc_hd__decap_3
XFILLER_69_615 VGND VGND VPWR VPWR sky130_fd_sc_hd__fill_1
XFILLER_96_412 VGND VGND VPWR VPWR sky130_fd_sc_hd__decap_3
XFILLER_110_222 VGND VGND VPWR VPWR sky130_fd_sc_hd__decap_3
XFILLER_68_125 VGND VGND VPWR VPWR sky130_fd_sc_hd__decap_3
XFILLER_68_136 VGND VGND VPWR VPWR sky130_fd_sc_hd__decap_3
XFILLER_69_659 VGND VGND VPWR VPWR sky130_fd_sc_hd__decap_3
XFILLER_78_91 VGND VGND VPWR VPWR sky130_fd_sc_hd__decap_3
X_5090_ _5103_/A1 _5083_/X _5085_/X _5089_/Y VGND VGND VPWR VPWR _5658_/C sky130_fd_sc_hd__a31o_2
X_4110_ _4376_/A _4141_/A _4141_/B _4142_/C VGND VGND VPWR VPWR _4111_/B sky130_fd_sc_hd__or4_4
XFILLER_56_309 VGND VGND VPWR VPWR sky130_fd_sc_hd__fill_1
XFILLER_68_147 VGND VGND VPWR VPWR sky130_fd_sc_hd__decap_3
XFILLER_84_607 VGND VGND VPWR VPWR sky130_fd_sc_hd__fill_2
XFILLER_96_489 VGND VGND VPWR VPWR sky130_fd_sc_hd__decap_3
X_4041_ _7245_/Q _4430_/A2 _5229_/C _7149_/Q VGND VGND VPWR VPWR _4041_/X sky130_fd_sc_hd__a22o_2
XFILLER_37_501 VGND VGND VPWR VPWR sky130_fd_sc_hd__decap_3
XFILLER_37_534 VGND VGND VPWR VPWR sky130_fd_sc_hd__fill_2
XFILLER_49_361 VGND VGND VPWR VPWR sky130_fd_sc_hd__decap_3
XFILLER_37_556 VGND VGND VPWR VPWR sky130_fd_sc_hd__decap_3
XFILLER_24_206 VGND VGND VPWR VPWR sky130_fd_sc_hd__decap_3
XFILLER_52_504 VGND VGND VPWR VPWR sky130_fd_sc_hd__decap_3
XFILLER_64_386 VGND VGND VPWR VPWR sky130_fd_sc_hd__decap_3
XFILLER_64_397 VGND VGND VPWR VPWR sky130_fd_sc_hd__decap_3
XFILLER_91_183 VGND VGND VPWR VPWR sky130_fd_sc_hd__decap_3
X_4943_ _4943_/A _4943_/B VGND VGND VPWR VPWR _4944_/C sky130_fd_sc_hd__nor2_2
XTAP_TAPCELL_ROW_65_1029 VGND VPWR sky130_fd_sc_hd__tapvpwrvgnd_1
XFILLER_32_250 VGND VGND VPWR VPWR sky130_fd_sc_hd__fill_2
XFILLER_32_261 VGND VGND VPWR VPWR sky130_fd_sc_hd__decap_3
XFILLER_32_283 VGND VGND VPWR VPWR sky130_fd_sc_hd__decap_3
X_6613_ _6643_/A VGND VGND VPWR VPWR _6613_/Y sky130_fd_sc_hd__inv_2
X_4874_ _4814_/A _4849_/Y _4872_/X _4873_/X VGND VGND VPWR VPWR _4874_/X sky130_fd_sc_hd__o31a_2
XFILLER_20_456 VGND VGND VPWR VPWR sky130_fd_sc_hd__decap_3
XFILLER_20_467 VGND VGND VPWR VPWR sky130_fd_sc_hd__fill_1
X_3825_ _6749_/Q _3869_/A2 _3825_/B1 _6737_/Q VGND VGND VPWR VPWR _3825_/X sky130_fd_sc_hd__a22o_2
X_6544_ _6548_/A VGND VGND VPWR VPWR _6544_/Y sky130_fd_sc_hd__inv_2
X_3756_ _6798_/Q _3922_/A2 _3863_/A2 _6708_/Q _3755_/X VGND VGND VPWR VPWR _3756_/X
+ sky130_fd_sc_hd__a221o_2
X_6475_ _6535_/A VGND VGND VPWR VPWR _6475_/Y sky130_fd_sc_hd__inv_2
XFILLER_106_517 VGND VGND VPWR VPWR sky130_fd_sc_hd__decap_3
XTAP_TAPCELL_ROW_76_1158 VGND VPWR sky130_fd_sc_hd__tapvpwrvgnd_1
XTAP_TAPCELL_ROW_76_1169 VGND VPWR sky130_fd_sc_hd__tapvpwrvgnd_1
XFILLER_99_261 VGND VGND VPWR VPWR sky130_fd_sc_hd__decap_3
XFILLER_101_222 VGND VGND VPWR VPWR sky130_fd_sc_hd__fill_2
XFILLER_59_125 VGND VGND VPWR VPWR sky130_fd_sc_hd__decap_3
XFILLER_87_434 VGND VGND VPWR VPWR sky130_fd_sc_hd__fill_2
X_5288_ _5288_/A0 _3993_/X _5292_/S VGND VGND VPWR VPWR _7185_/D sky130_fd_sc_hd__mux2_2
X_4308_ _7192_/Q _3989_/S _4332_/B1 _7384_/Q VGND VGND VPWR VPWR _4308_/X sky130_fd_sc_hd__a22o_2
XFILLER_59_169 VGND VGND VPWR VPWR sky130_fd_sc_hd__decap_3
XFILLER_75_629 VGND VGND VPWR VPWR sky130_fd_sc_hd__decap_3
X_7027_ _7371_/CLK _7027_/D _6307_/Y VGND VGND VPWR VPWR _7027_/Q sky130_fd_sc_hd__dfrtp_2
X_4239_ _4628_/A _4629_/B VGND VGND VPWR VPWR _5018_/B sky130_fd_sc_hd__nor2_2
XFILLER_101_299 VGND VGND VPWR VPWR sky130_fd_sc_hd__decap_3
XFILLER_114_56 VGND VGND VPWR VPWR sky130_fd_sc_hd__decap_3
XFILLER_74_106 VGND VGND VPWR VPWR sky130_fd_sc_hd__decap_3
XFILLER_67_180 VGND VGND VPWR VPWR sky130_fd_sc_hd__decap_3
XFILLER_83_640 VGND VGND VPWR VPWR sky130_fd_sc_hd__decap_3
XFILLER_28_578 VGND VGND VPWR VPWR sky130_fd_sc_hd__fill_2
XFILLER_82_150 VGND VGND VPWR VPWR sky130_fd_sc_hd__decap_3
XFILLER_83_673 VGND VGND VPWR VPWR sky130_fd_sc_hd__decap_3
XFILLER_15_228 VGND VGND VPWR VPWR sky130_fd_sc_hd__decap_3
XFILLER_70_323 VGND VGND VPWR VPWR sky130_fd_sc_hd__decap_3
XFILLER_82_183 VGND VGND VPWR VPWR sky130_fd_sc_hd__decap_3
XTAP_TAPCELL_ROW_87_1298 VGND VPWR sky130_fd_sc_hd__tapvpwrvgnd_1
XFILLER_70_356 VGND VGND VPWR VPWR sky130_fd_sc_hd__decap_3
XFILLER_90_26 VGND VGND VPWR VPWR sky130_fd_sc_hd__fill_2
XFILLER_23_272 VGND VGND VPWR VPWR sky130_fd_sc_hd__decap_3
XTAP_TAPCELL_ROW_41_749 VGND VPWR sky130_fd_sc_hd__tapvpwrvgnd_1
XTAP_TAPCELL_ROW_41_738 VGND VPWR sky130_fd_sc_hd__tapvpwrvgnd_1
XTAP_TAPCELL_ROW_13_407 VGND VPWR sky130_fd_sc_hd__tapvpwrvgnd_1
XFILLER_23_53 VGND VGND VPWR VPWR sky130_fd_sc_hd__decap_3
XFILLER_109_322 VGND VGND VPWR VPWR sky130_fd_sc_hd__decap_3
XFILLER_23_75 VGND VGND VPWR VPWR sky130_fd_sc_hd__decap_3
XFILLER_7_449 VGND VGND VPWR VPWR sky130_fd_sc_hd__decap_3
XFILLER_109_355 VGND VGND VPWR VPWR sky130_fd_sc_hd__decap_3
XFILLER_109_388 VGND VGND VPWR VPWR sky130_fd_sc_hd__decap_3
XFILLER_109_399 VGND VGND VPWR VPWR sky130_fd_sc_hd__decap_3
XFILLER_105_561 VGND VGND VPWR VPWR sky130_fd_sc_hd__decap_3
XFILLER_97_209 VGND VGND VPWR VPWR sky130_fd_sc_hd__fill_2
XFILLER_78_434 VGND VGND VPWR VPWR sky130_fd_sc_hd__decap_3
XFILLER_78_467 VGND VGND VPWR VPWR sky130_fd_sc_hd__decap_3
XFILLER_17_9 VGND VGND VPWR VPWR sky130_fd_sc_hd__decap_3
XFILLER_78_489 VGND VGND VPWR VPWR sky130_fd_sc_hd__fill_1
XTAP_TAPCELL_ROW_49_838 VGND VPWR sky130_fd_sc_hd__tapvpwrvgnd_1
XFILLER_0_35 VGND VGND VPWR VPWR sky130_fd_sc_hd__decap_3
XFILLER_46_342 VGND VGND VPWR VPWR sky130_fd_sc_hd__decap_3
XFILLER_58_180 VGND VGND VPWR VPWR sky130_fd_sc_hd__decap_3
XFILLER_65_139 VGND VGND VPWR VPWR sky130_fd_sc_hd__decap_3
XFILLER_93_459 VGND VGND VPWR VPWR sky130_fd_sc_hd__decap_3
XFILLER_0_68 VGND VGND VPWR VPWR sky130_fd_sc_hd__fill_1
XFILLER_46_386 VGND VGND VPWR VPWR sky130_fd_sc_hd__decap_3
XFILLER_73_172 VGND VGND VPWR VPWR sky130_fd_sc_hd__decap_3
XTAP_TAPCELL_ROW_29_595 VGND VPWR sky130_fd_sc_hd__tapvpwrvgnd_1
XFILLER_61_367 VGND VGND VPWR VPWR sky130_fd_sc_hd__decap_3
XFILLER_61_378 VGND VGND VPWR VPWR sky130_fd_sc_hd__decap_3
XFILLER_64_93 VGND VGND VPWR VPWR sky130_fd_sc_hd__decap_3
XFILLER_9_44 VGND VGND VPWR VPWR sky130_fd_sc_hd__decap_3
XFILLER_9_22 VGND VGND VPWR VPWR sky130_fd_sc_hd__decap_3
XFILLER_9_66 VGND VGND VPWR VPWR sky130_fd_sc_hd__decap_3
XFILLER_80_81 VGND VGND VPWR VPWR sky130_fd_sc_hd__decap_3
X_3610_ _3610_/A _3610_/B VGND VGND VPWR VPWR _3610_/Y sky130_fd_sc_hd__nor2_2
XPHY_EDGE_ROW_104_Right_104 VGND VGND VPWR VPWR sky130_fd_sc_hd__decap_3
XFILLER_9_99 VGND VGND VPWR VPWR sky130_fd_sc_hd__fill_1
X_3541_ _4376_/A _3541_/B _4460_/B VGND VGND VPWR VPWR _3541_/X sky130_fd_sc_hd__or3b_4
Xhold906 _7077_/Q VGND VGND VPWR VPWR _7077_/D sky130_fd_sc_hd__dlygate4sd3_1
Xhold917 _6697_/Q VGND VGND VPWR VPWR hold917/X sky130_fd_sc_hd__dlygate4sd3_1
Xhold928 _6701_/Q VGND VGND VPWR VPWR hold928/X sky130_fd_sc_hd__dlygate4sd3_1
XFILLER_115_347 VGND VGND VPWR VPWR sky130_fd_sc_hd__decap_3
XFILLER_50_3 VGND VGND VPWR VPWR sky130_fd_sc_hd__decap_3
Xhold939 _7023_/Q VGND VGND VPWR VPWR _5609_/A sky130_fd_sc_hd__dlygate4sd3_1
X_6260_ _6385_/A VGND VGND VPWR VPWR _6260_/Y sky130_fd_sc_hd__inv_2
X_3472_ _7216_/Q _4340_/A2 _4348_/B1 _7120_/Q VGND VGND VPWR VPWR _3472_/X sky130_fd_sc_hd__a22o_2
XFILLER_89_90 VGND VGND VPWR VPWR sky130_fd_sc_hd__decap_3
X_5211_ _7223_/Q _5225_/B VGND VGND VPWR VPWR _7223_/D sky130_fd_sc_hd__and2_2
XFILLER_69_423 VGND VGND VPWR VPWR sky130_fd_sc_hd__decap_3
X_5142_ _5142_/A0 _3993_/X _5159_/S VGND VGND VPWR VPWR _7249_/D sky130_fd_sc_hd__mux2_2
XFILLER_111_564 VGND VGND VPWR VPWR sky130_fd_sc_hd__fill_2
XFILLER_96_286 VGND VGND VPWR VPWR sky130_fd_sc_hd__decap_3
X_5073_ _5073_/A _5073_/B VGND VGND VPWR VPWR _5073_/Y sky130_fd_sc_hd__xnor2_2
XTAP_TAPCELL_ROW_71_1099 VGND VPWR sky130_fd_sc_hd__tapvpwrvgnd_1
XFILLER_37_331 VGND VGND VPWR VPWR sky130_fd_sc_hd__decap_3
XFILLER_65_640 VGND VGND VPWR VPWR sky130_fd_sc_hd__decap_3
XFILLER_84_459 VGND VGND VPWR VPWR sky130_fd_sc_hd__decap_3
XFILLER_37_364 VGND VGND VPWR VPWR sky130_fd_sc_hd__decap_3
XFILLER_71_109 VGND VGND VPWR VPWR sky130_fd_sc_hd__decap_3
XFILLER_92_470 VGND VGND VPWR VPWR sky130_fd_sc_hd__decap_3
XFILLER_25_559 VGND VGND VPWR VPWR sky130_fd_sc_hd__fill_1
XFILLER_37_386 VGND VGND VPWR VPWR sky130_fd_sc_hd__decap_3
XFILLER_44_19 VGND VGND VPWR VPWR sky130_fd_sc_hd__decap_3
XFILLER_52_312 VGND VGND VPWR VPWR sky130_fd_sc_hd__decap_3
XFILLER_64_172 VGND VGND VPWR VPWR sky130_fd_sc_hd__fill_2
XFILLER_64_194 VGND VGND VPWR VPWR sky130_fd_sc_hd__fill_2
XFILLER_80_632 VGND VGND VPWR VPWR sky130_fd_sc_hd__decap_3
XFILLER_92_492 VGND VGND VPWR VPWR sky130_fd_sc_hd__decap_3
XFILLER_12_209 VGND VGND VPWR VPWR sky130_fd_sc_hd__decap_3
XFILLER_52_345 VGND VGND VPWR VPWR sky130_fd_sc_hd__decap_3
XFILLER_40_529 VGND VGND VPWR VPWR sky130_fd_sc_hd__decap_3
X_4926_ _4948_/A _4920_/Y _4925_/X VGND VGND VPWR VPWR _4926_/Y sky130_fd_sc_hd__o21ai_2
XFILLER_100_47 VGND VGND VPWR VPWR sky130_fd_sc_hd__decap_3
XFILLER_20_242 VGND VGND VPWR VPWR sky130_fd_sc_hd__fill_1
XFILLER_60_18 VGND VGND VPWR VPWR sky130_fd_sc_hd__decap_3
X_4857_ _4975_/A _5655_/D wire556/X VGND VGND VPWR VPWR _4857_/X sky130_fd_sc_hd__or3b_4
XFILLER_20_253 VGND VGND VPWR VPWR sky130_fd_sc_hd__decap_3
X_3808_ _6929_/Q _3912_/A2 _3926_/B1 _6793_/Q _3807_/X VGND VGND VPWR VPWR _3808_/X
+ sky130_fd_sc_hd__a221o_2
XFILLER_109_12 VGND VGND VPWR VPWR sky130_fd_sc_hd__decap_3
X_6527_ _6637_/A VGND VGND VPWR VPWR _6527_/Y sky130_fd_sc_hd__inv_2
X_4788_ _4788_/A _4788_/B VGND VGND VPWR VPWR _4788_/Y sky130_fd_sc_hd__nand2_2
XFILLER_106_303 VGND VGND VPWR VPWR sky130_fd_sc_hd__decap_3
XFILLER_109_34 VGND VGND VPWR VPWR sky130_fd_sc_hd__decap_3
X_3739_ _6936_/Q _3912_/A2 _3913_/A2 _6800_/Q VGND VGND VPWR VPWR _3739_/X sky130_fd_sc_hd__a22o_2
XFILLER_109_89 VGND VGND VPWR VPWR sky130_fd_sc_hd__decap_3
XFILLER_69_27 VGND VGND VPWR VPWR sky130_fd_sc_hd__decap_3
X_6458_ _6682_/A VGND VGND VPWR VPWR _6458_/Y sky130_fd_sc_hd__inv_2
XFILLER_69_49 VGND VGND VPWR VPWR sky130_fd_sc_hd__decap_3
X_6389_ _6611_/A VGND VGND VPWR VPWR _6389_/Y sky130_fd_sc_hd__inv_2
X_5409_ _5409_/A0 _5079_/X _5429_/S VGND VGND VPWR VPWR _7129_/D sky130_fd_sc_hd__mux2_2
XFILLER_0_614 VGND VGND VPWR VPWR sky130_fd_sc_hd__fill_2
XFILLER_102_531 VGND VGND VPWR VPWR sky130_fd_sc_hd__fill_1
XFILLER_114_391 VGND VGND VPWR VPWR sky130_fd_sc_hd__decap_3
XFILLER_85_26 VGND VGND VPWR VPWR sky130_fd_sc_hd__decap_3
XFILLER_102_575 VGND VGND VPWR VPWR sky130_fd_sc_hd__fill_1
XFILLER_85_48 VGND VGND VPWR VPWR sky130_fd_sc_hd__decap_3
XFILLER_87_275 VGND VGND VPWR VPWR sky130_fd_sc_hd__decap_3
XTAP_TAPCELL_ROW_89_1316 VGND VPWR sky130_fd_sc_hd__tapvpwrvgnd_1
XFILLER_18_20 VGND VGND VPWR VPWR sky130_fd_sc_hd__decap_3
XFILLER_28_353 VGND VGND VPWR VPWR sky130_fd_sc_hd__decap_3
XFILLER_28_375 VGND VGND VPWR VPWR sky130_fd_sc_hd__decap_3
XTAP_TAPCELL_ROW_46_808 VGND VPWR sky130_fd_sc_hd__tapvpwrvgnd_1
XFILLER_18_97 VGND VGND VPWR VPWR sky130_fd_sc_hd__fill_1
XFILLER_55_172 VGND VGND VPWR VPWR sky130_fd_sc_hd__decap_3
XFILLER_71_632 VGND VGND VPWR VPWR sky130_fd_sc_hd__decap_3
XFILLER_70_131 VGND VGND VPWR VPWR sky130_fd_sc_hd__decap_3
XFILLER_71_676 VGND VGND VPWR VPWR sky130_fd_sc_hd__decap_3
XFILLER_43_389 VGND VGND VPWR VPWR sky130_fd_sc_hd__decap_3
XFILLER_70_175 VGND VGND VPWR VPWR sky130_fd_sc_hd__decap_3
XTAP_TAPCELL_ROW_54_896 VGND VPWR sky130_fd_sc_hd__tapvpwrvgnd_1
XTAP_TAPCELL_ROW_26_565 VGND VPWR sky130_fd_sc_hd__tapvpwrvgnd_1
XFILLER_11_220 VGND VGND VPWR VPWR sky130_fd_sc_hd__fill_1
XFILLER_34_85 VGND VGND VPWR VPWR sky130_fd_sc_hd__decap_3
XFILLER_7_202 VGND VGND VPWR VPWR sky130_fd_sc_hd__decap_3
XFILLER_109_163 VGND VGND VPWR VPWR sky130_fd_sc_hd__fill_2
XFILLER_50_73 VGND VGND VPWR VPWR sky130_fd_sc_hd__decap_3
XFILLER_7_268 VGND VGND VPWR VPWR sky130_fd_sc_hd__decap_3
XFILLER_109_185 VGND VGND VPWR VPWR sky130_fd_sc_hd__decap_3
XFILLER_112_317 VGND VGND VPWR VPWR sky130_fd_sc_hd__decap_3
XFILLER_3_452 VGND VGND VPWR VPWR sky130_fd_sc_hd__fill_2
XFILLER_98_507 VGND VGND VPWR VPWR sky130_fd_sc_hd__decap_3
XFILLER_59_60 VGND VGND VPWR VPWR sky130_fd_sc_hd__decap_3
XFILLER_105_391 VGND VGND VPWR VPWR sky130_fd_sc_hd__fill_1
XFILLER_59_93 VGND VGND VPWR VPWR sky130_fd_sc_hd__decap_3
XFILLER_78_253 VGND VGND VPWR VPWR sky130_fd_sc_hd__decap_3
XFILLER_38_106 VGND VGND VPWR VPWR sky130_fd_sc_hd__decap_3
XFILLER_15_6 VGND VGND VPWR VPWR sky130_fd_sc_hd__decap_3
XFILLER_19_320 VGND VGND VPWR VPWR sky130_fd_sc_hd__decap_3
XFILLER_38_139 VGND VGND VPWR VPWR sky130_fd_sc_hd__fill_1
XFILLER_66_448 VGND VGND VPWR VPWR sky130_fd_sc_hd__decap_3
XFILLER_93_223 VGND VGND VPWR VPWR sky130_fd_sc_hd__fill_1
XFILLER_93_256 VGND VGND VPWR VPWR sky130_fd_sc_hd__decap_3
XFILLER_46_150 VGND VGND VPWR VPWR sky130_fd_sc_hd__decap_3
XFILLER_47_673 VGND VGND VPWR VPWR sky130_fd_sc_hd__fill_2
XTAP_TAPCELL_ROW_109_1563 VGND VPWR sky130_fd_sc_hd__tapvpwrvgnd_1
XFILLER_34_301 VGND VGND VPWR VPWR sky130_fd_sc_hd__decap_3
XFILLER_34_312 VGND VGND VPWR VPWR sky130_fd_sc_hd__decap_3
XFILLER_46_194 VGND VGND VPWR VPWR sky130_fd_sc_hd__fill_2
XFILLER_62_643 VGND VGND VPWR VPWR sky130_fd_sc_hd__fill_1
XFILLER_74_470 VGND VGND VPWR VPWR sky130_fd_sc_hd__decap_3
XFILLER_34_345 VGND VGND VPWR VPWR sky130_fd_sc_hd__decap_3
XFILLER_61_175 VGND VGND VPWR VPWR sky130_fd_sc_hd__decap_3
XFILLER_98_3 VGND VGND VPWR VPWR sky130_fd_sc_hd__decap_3
X_4711_ _7005_/Q _7006_/Q _4775_/A VGND VGND VPWR VPWR _4738_/A sky130_fd_sc_hd__and3_2
X_4642_ _4207_/A _4642_/B VGND VGND VPWR VPWR _4888_/A sky130_fd_sc_hd__and2b_2
XFILLER_116_612 VGND VGND VPWR VPWR sky130_fd_sc_hd__decap_3
XFILLER_116_623 VGND VGND VPWR VPWR sky130_fd_sc_hd__decap_3
X_7361_ _7361_/CLK _7361_/D _6641_/Y VGND VGND VPWR VPWR _7361_/Q sky130_fd_sc_hd__dfrtp_2
Xhold703 _6724_/Q VGND VGND VPWR VPWR _6724_/D sky130_fd_sc_hd__dlygate4sd3_1
X_4573_ _7294_/Q _4583_/B VGND VGND VPWR VPWR _7294_/D sky130_fd_sc_hd__and2_2
XFILLER_115_111 VGND VGND VPWR VPWR sky130_fd_sc_hd__fill_1
X_7292_ _7396_/CLK _7292_/D _6572_/Y VGND VGND VPWR VPWR _7292_/Q sky130_fd_sc_hd__dfrtp_2
Xhold714 _6977_/Q VGND VGND VPWR VPWR _6977_/D sky130_fd_sc_hd__dlygate4sd3_1
Xhold725 _6907_/Q VGND VGND VPWR VPWR _6907_/D sky130_fd_sc_hd__dlygate4sd3_1
Xhold736 _6976_/Q VGND VGND VPWR VPWR _6976_/D sky130_fd_sc_hd__dlygate4sd3_1
X_6312_ _6634_/A VGND VGND VPWR VPWR _6312_/Y sky130_fd_sc_hd__inv_2
Xhold747 _6770_/Q VGND VGND VPWR VPWR _6770_/D sky130_fd_sc_hd__dlygate4sd3_1
Xhold758 _6824_/Q VGND VGND VPWR VPWR _6824_/D sky130_fd_sc_hd__dlygate4sd3_1
Xhold769 _6822_/Q VGND VGND VPWR VPWR _6822_/D sky130_fd_sc_hd__dlygate4sd3_1
X_3455_ _7346_/Q _4270_/B _3454_/X VGND VGND VPWR VPWR _3455_/X sky130_fd_sc_hd__a21o_2
XTAP_TAPCELL_ROW_73_1128 VGND VPWR sky130_fd_sc_hd__tapvpwrvgnd_1
XFILLER_103_317 VGND VGND VPWR VPWR sky130_fd_sc_hd__decap_3
XFILLER_69_231 VGND VGND VPWR VPWR sky130_fd_sc_hd__decap_3
X_3386_ _3386_/A _3386_/B VGND VGND VPWR VPWR _3386_/Y sky130_fd_sc_hd__nand2_2
XFILLER_69_264 VGND VGND VPWR VPWR sky130_fd_sc_hd__decap_3
X_5125_ _5156_/S _5125_/B VGND VGND VPWR VPWR _5125_/Y sky130_fd_sc_hd__nand2_2
XFILLER_29_128 VGND VGND VPWR VPWR sky130_fd_sc_hd__decap_3
XFILLER_84_234 VGND VGND VPWR VPWR sky130_fd_sc_hd__decap_3
X_5056_ _3536_/B _4619_/B _5052_/X _5055_/X VGND VGND VPWR VPWR _5056_/X sky130_fd_sc_hd__o31a_2
XFILLER_38_662 VGND VGND VPWR VPWR sky130_fd_sc_hd__fill_1
XFILLER_72_407 VGND VGND VPWR VPWR sky130_fd_sc_hd__decap_3
XFILLER_84_267 VGND VGND VPWR VPWR sky130_fd_sc_hd__fill_1
XFILLER_111_13 VGND VGND VPWR VPWR sky130_fd_sc_hd__decap_3
XFILLER_25_323 VGND VGND VPWR VPWR sky130_fd_sc_hd__decap_3
XFILLER_37_161 VGND VGND VPWR VPWR sky130_fd_sc_hd__decap_3
XFILLER_37_172 VGND VGND VPWR VPWR sky130_fd_sc_hd__decap_3
XFILLER_65_492 VGND VGND VPWR VPWR sky130_fd_sc_hd__decap_3
XFILLER_111_46 VGND VGND VPWR VPWR sky130_fd_sc_hd__decap_3
XFILLER_25_367 VGND VGND VPWR VPWR sky130_fd_sc_hd__decap_3
XFILLER_52_131 VGND VGND VPWR VPWR sky130_fd_sc_hd__decap_3
XFILLER_52_153 VGND VGND VPWR VPWR sky130_fd_sc_hd__decap_3
XFILLER_80_451 VGND VGND VPWR VPWR sky130_fd_sc_hd__decap_3
XFILLER_80_462 VGND VGND VPWR VPWR sky130_fd_sc_hd__decap_3
XTAP_TAPCELL_ROW_84_1257 VGND VPWR sky130_fd_sc_hd__tapvpwrvgnd_1
XFILLER_111_57 VGND VGND VPWR VPWR sky130_fd_sc_hd__decap_3
XFILLER_40_315 VGND VGND VPWR VPWR sky130_fd_sc_hd__decap_3
XFILLER_71_28 VGND VGND VPWR VPWR sky130_fd_sc_hd__fill_2
XFILLER_80_495 VGND VGND VPWR VPWR sky130_fd_sc_hd__decap_3
XFILLER_40_348 VGND VGND VPWR VPWR sky130_fd_sc_hd__decap_3
XFILLER_52_197 VGND VGND VPWR VPWR sky130_fd_sc_hd__fill_1
X_4909_ _5647_/A _4909_/B _4909_/C VGND VGND VPWR VPWR _4910_/B sky130_fd_sc_hd__or3_2
XTAP_TAPCELL_ROW_23_524 VGND VPWR sky130_fd_sc_hd__tapvpwrvgnd_1
XTAP_TAPCELL_ROW_51_866 VGND VPWR sky130_fd_sc_hd__tapvpwrvgnd_1
XFILLER_106_122 VGND VGND VPWR VPWR sky130_fd_sc_hd__decap_3
XFILLER_107_656 VGND VGND VPWR VPWR sky130_fd_sc_hd__decap_3
XFILLER_20_32 VGND VGND VPWR VPWR sky130_fd_sc_hd__decap_3
XFILLER_106_144 VGND VGND VPWR VPWR sky130_fd_sc_hd__fill_1
XFILLER_106_155 VGND VGND VPWR VPWR sky130_fd_sc_hd__decap_3
XFILLER_20_65 VGND VGND VPWR VPWR sky130_fd_sc_hd__decap_3
XTAP_TAPCELL_ROW_95_1397 VGND VPWR sky130_fd_sc_hd__tapvpwrvgnd_1
XTAP_TAPCELL_ROW_95_1386 VGND VPWR sky130_fd_sc_hd__tapvpwrvgnd_1
XFILLER_96_14 VGND VGND VPWR VPWR sky130_fd_sc_hd__decap_3
XFILLER_29_41 VGND VGND VPWR VPWR sky130_fd_sc_hd__decap_3
XFILLER_88_584 VGND VGND VPWR VPWR sky130_fd_sc_hd__decap_3
XFILLER_88_595 VGND VGND VPWR VPWR sky130_fd_sc_hd__decap_3
XFILLER_29_63 VGND VGND VPWR VPWR sky130_fd_sc_hd__decap_3
XFILLER_29_96 VGND VGND VPWR VPWR sky130_fd_sc_hd__decap_3
XFILLER_48_448 VGND VGND VPWR VPWR sky130_fd_sc_hd__decap_3
XFILLER_75_234 VGND VGND VPWR VPWR sky130_fd_sc_hd__decap_3
XTAP_TAPCELL_ROW_59_955 VGND VPWR sky130_fd_sc_hd__tapvpwrvgnd_1
XFILLER_28_150 VGND VGND VPWR VPWR sky130_fd_sc_hd__decap_3
XFILLER_29_673 VGND VGND VPWR VPWR sky130_fd_sc_hd__decap_3
XFILLER_75_278 VGND VGND VPWR VPWR sky130_fd_sc_hd__fill_2
XFILLER_90_204 VGND VGND VPWR VPWR sky130_fd_sc_hd__decap_3
XFILLER_16_301 VGND VGND VPWR VPWR sky130_fd_sc_hd__decap_3
XFILLER_28_183 VGND VGND VPWR VPWR sky130_fd_sc_hd__decap_3
XFILLER_56_492 VGND VGND VPWR VPWR sky130_fd_sc_hd__decap_3
XFILLER_63_429 VGND VGND VPWR VPWR sky130_fd_sc_hd__decap_3
XFILLER_90_237 VGND VGND VPWR VPWR sky130_fd_sc_hd__decap_3
Xplace407 _4534_/S VGND VGND VPWR VPWR _4532_/S sky130_fd_sc_hd__buf_2
Xplace418 _4332_/B1 VGND VGND VPWR VPWR _4338_/B1 sky130_fd_sc_hd__buf_2
Xplace429 _3996_/S VGND VGND VPWR VPWR _4471_/S sky130_fd_sc_hd__buf_2
XTAP_TAPCELL_ROW_3_293 VGND VPWR sky130_fd_sc_hd__tapvpwrvgnd_1
XTAP_TAPCELL_ROW_3_282 VGND VPWR sky130_fd_sc_hd__tapvpwrvgnd_1
XFILLER_16_345 VGND VGND VPWR VPWR sky130_fd_sc_hd__decap_3
XFILLER_45_73 VGND VGND VPWR VPWR sky130_fd_sc_hd__decap_3
XFILLER_43_175 VGND VGND VPWR VPWR sky130_fd_sc_hd__decap_3
XFILLER_71_484 VGND VGND VPWR VPWR sky130_fd_sc_hd__decap_3
XFILLER_31_337 VGND VGND VPWR VPWR sky130_fd_sc_hd__decap_3
XFILLER_101_90 VGND VGND VPWR VPWR sky130_fd_sc_hd__decap_3
XFILLER_61_50 VGND VGND VPWR VPWR sky130_fd_sc_hd__decap_3
XFILLER_84_9 VGND VGND VPWR VPWR sky130_fd_sc_hd__decap_3
XFILLER_8_522 VGND VGND VPWR VPWR sky130_fd_sc_hd__fill_1
XFILLER_61_72 VGND VGND VPWR VPWR sky130_fd_sc_hd__decap_3
XANTENNA_5 _4664_/B VGND VGND VPWR VPWR sky130_fd_sc_hd__diode_2
XFILLER_6_45 VGND VGND VPWR VPWR sky130_fd_sc_hd__fill_2
XFILLER_6_67 VGND VGND VPWR VPWR sky130_fd_sc_hd__decap_3
XFILLER_112_114 VGND VGND VPWR VPWR sky130_fd_sc_hd__decap_3
XFILLER_98_326 VGND VGND VPWR VPWR sky130_fd_sc_hd__decap_3
XFILLER_98_315 VGND VGND VPWR VPWR sky130_fd_sc_hd__decap_3
XFILLER_3_293 VGND VGND VPWR VPWR sky130_fd_sc_hd__decap_3
XFILLER_39_426 VGND VGND VPWR VPWR sky130_fd_sc_hd__fill_1
XFILLER_66_212 VGND VGND VPWR VPWR sky130_fd_sc_hd__decap_3
XFILLER_66_245 VGND VGND VPWR VPWR sky130_fd_sc_hd__decap_3
XFILLER_86_80 VGND VGND VPWR VPWR sky130_fd_sc_hd__decap_3
XFILLER_86_91 VGND VGND VPWR VPWR sky130_fd_sc_hd__decap_3
XFILLER_94_521 VGND VGND VPWR VPWR sky130_fd_sc_hd__decap_3
XFILLER_54_418 VGND VGND VPWR VPWR sky130_fd_sc_hd__fill_2
XFILLER_66_256 VGND VGND VPWR VPWR sky130_fd_sc_hd__decap_3
XFILLER_19_161 VGND VGND VPWR VPWR sky130_fd_sc_hd__decap_3
XFILLER_19_172 VGND VGND VPWR VPWR sky130_fd_sc_hd__decap_3
XFILLER_35_610 VGND VGND VPWR VPWR sky130_fd_sc_hd__decap_3
XFILLER_66_289 VGND VGND VPWR VPWR sky130_fd_sc_hd__decap_3
XFILLER_81_237 VGND VGND VPWR VPWR sky130_fd_sc_hd__decap_3
X_6930_ _7384_/CLK _6930_/D VGND VGND VPWR VPWR _6930_/Q sky130_fd_sc_hd__dfxtp_2
XFILLER_19_194 VGND VGND VPWR VPWR sky130_fd_sc_hd__decap_3
XFILLER_34_120 VGND VGND VPWR VPWR sky130_fd_sc_hd__decap_3
XFILLER_62_451 VGND VGND VPWR VPWR sky130_fd_sc_hd__decap_3
X_6861_ _6909_/CLK _6861_/D VGND VGND VPWR VPWR _6861_/Q sky130_fd_sc_hd__dfxtp_2
XFILLER_34_164 VGND VGND VPWR VPWR sky130_fd_sc_hd__decap_3
X_6792_ _7390_/CLK _6792_/D VGND VGND VPWR VPWR _6792_/Q sky130_fd_sc_hd__dfxtp_2
XFILLER_22_348 VGND VGND VPWR VPWR sky130_fd_sc_hd__decap_3
XFILLER_34_197 VGND VGND VPWR VPWR sky130_fd_sc_hd__decap_3
XFILLER_62_495 VGND VGND VPWR VPWR sky130_fd_sc_hd__fill_1
XFILLER_30_392 VGND VGND VPWR VPWR sky130_fd_sc_hd__decap_3
X_5674_ _7343_/Q hold913/X _5706_/S VGND VGND VPWR VPWR _5674_/X sky130_fd_sc_hd__mux2_2
X_4625_ _5099_/A _4625_/A2 _4624_/B _4624_/X VGND VGND VPWR VPWR _4916_/A sky130_fd_sc_hd__a31oi_4
X_7344_ _7381_/CLK _7344_/D _6624_/Y VGND VGND VPWR VPWR _7344_/Q sky130_fd_sc_hd__dfrtp_2
X_4556_ _4556_/A _4569_/B VGND VGND VPWR VPWR _7302_/D sky130_fd_sc_hd__and2_2
XFILLER_116_464 VGND VGND VPWR VPWR sky130_fd_sc_hd__decap_3
X_3507_ _3458_/Y _3505_/X _3506_/Y VGND VGND VPWR VPWR _3508_/B sky130_fd_sc_hd__o21a_2
XFILLER_103_103 VGND VGND VPWR VPWR sky130_fd_sc_hd__fill_2
XFILLER_104_615 VGND VGND VPWR VPWR sky130_fd_sc_hd__fill_1
XFILLER_116_486 VGND VGND VPWR VPWR sky130_fd_sc_hd__fill_1
XFILLER_1_208 VGND VGND VPWR VPWR sky130_fd_sc_hd__decap_3
XFILLER_89_337 VGND VGND VPWR VPWR sky130_fd_sc_hd__fill_2
X_7275_ _7371_/CLK _7275_/D _6555_/Y VGND VGND VPWR VPWR _7275_/Q sky130_fd_sc_hd__dfrtp_2
Xhold588 _6922_/Q VGND VGND VPWR VPWR _6922_/D sky130_fd_sc_hd__dlygate4sd3_1
Xhold599 _6912_/Q VGND VGND VPWR VPWR _6912_/D sky130_fd_sc_hd__dlygate4sd3_1
X_3438_ _7314_/Q _3989_/S _4338_/B1 _7346_/Q _4248_/A VGND VGND VPWR VPWR _3438_/X
+ sky130_fd_sc_hd__a221o_2
XFILLER_103_169 VGND VGND VPWR VPWR sky130_fd_sc_hd__decap_3
XFILLER_106_68 VGND VGND VPWR VPWR sky130_fd_sc_hd__decap_3
XFILLER_57_201 VGND VGND VPWR VPWR sky130_fd_sc_hd__fill_2
Xhold1200 _7166_/Q VGND VGND VPWR VPWR _5329_/A0 sky130_fd_sc_hd__dlygate4sd3_1
X_3369_ _3371_/A _5668_/A VGND VGND VPWR VPWR _3560_/B sky130_fd_sc_hd__nand2_2
XFILLER_57_234 VGND VGND VPWR VPWR sky130_fd_sc_hd__decap_3
XFILLER_85_543 VGND VGND VPWR VPWR sky130_fd_sc_hd__decap_3
Xhold1211 _7326_/Q VGND VGND VPWR VPWR _3964_/A1 sky130_fd_sc_hd__dlygate4sd3_1
X_5108_ _5108_/A0 _5107_/X _5132_/S VGND VGND VPWR VPWR _7255_/D sky130_fd_sc_hd__mux2_2
XFILLER_57_278 VGND VGND VPWR VPWR sky130_fd_sc_hd__fill_2
XFILLER_72_215 VGND VGND VPWR VPWR sky130_fd_sc_hd__fill_2
XFILLER_72_237 VGND VGND VPWR VPWR sky130_fd_sc_hd__decap_3
X_5039_ _4677_/B _3856_/X _5658_/B _5038_/X _5587_/B VGND VGND VPWR VPWR _5039_/X
+ sky130_fd_sc_hd__o32a_2
XTAP_TAPCELL_ROW_56_925 VGND VPWR sky130_fd_sc_hd__tapvpwrvgnd_1
XFILLER_25_131 VGND VGND VPWR VPWR sky130_fd_sc_hd__decap_3
XFILLER_82_27 VGND VGND VPWR VPWR sky130_fd_sc_hd__fill_1
XFILLER_82_38 VGND VGND VPWR VPWR sky130_fd_sc_hd__decap_3
XTAP_TAPCELL_ROW_0_252 VGND VPWR sky130_fd_sc_hd__tapvpwrvgnd_1
XTAP_TAPCELL_ROW_0_241 VGND VPWR sky130_fd_sc_hd__tapvpwrvgnd_1
XFILLER_13_315 VGND VGND VPWR VPWR sky130_fd_sc_hd__decap_3
XFILLER_15_21 VGND VGND VPWR VPWR sky130_fd_sc_hd__decap_3
XFILLER_25_175 VGND VGND VPWR VPWR sky130_fd_sc_hd__decap_3
XFILLER_53_484 VGND VGND VPWR VPWR sky130_fd_sc_hd__decap_3
XFILLER_13_326 VGND VGND VPWR VPWR sky130_fd_sc_hd__decap_3
XFILLER_15_54 VGND VGND VPWR VPWR sky130_fd_sc_hd__fill_2
XFILLER_40_112 VGND VGND VPWR VPWR sky130_fd_sc_hd__fill_2
XFILLER_80_292 VGND VGND VPWR VPWR sky130_fd_sc_hd__decap_3
XTAP_TAPCELL_ROW_36_682 VGND VPWR sky130_fd_sc_hd__tapvpwrvgnd_1
XFILLER_40_156 VGND VGND VPWR VPWR sky130_fd_sc_hd__decap_3
XFILLER_9_308 VGND VGND VPWR VPWR sky130_fd_sc_hd__fill_2
XFILLER_40_189 VGND VGND VPWR VPWR sky130_fd_sc_hd__decap_3
XTAP_TAPCELL_ROW_97_1415 VGND VPWR sky130_fd_sc_hd__tapvpwrvgnd_1
XFILLER_31_31 VGND VGND VPWR VPWR sky130_fd_sc_hd__decap_3
XFILLER_31_53 VGND VGND VPWR VPWR sky130_fd_sc_hd__decap_3
XFILLER_107_464 VGND VGND VPWR VPWR sky130_fd_sc_hd__decap_3
XTAP_TAPCELL_ROW_8_352 VGND VPWR sky130_fd_sc_hd__tapvpwrvgnd_1
XFILLER_76_510 VGND VGND VPWR VPWR sky130_fd_sc_hd__decap_3
XFILLER_95_318 VGND VGND VPWR VPWR sky130_fd_sc_hd__decap_3
XFILLER_48_256 VGND VGND VPWR VPWR sky130_fd_sc_hd__decap_3
XFILLER_56_50 VGND VGND VPWR VPWR sky130_fd_sc_hd__decap_3
XFILLER_76_587 VGND VGND VPWR VPWR sky130_fd_sc_hd__fill_1
XFILLER_56_83 VGND VGND VPWR VPWR sky130_fd_sc_hd__fill_1
XFILLER_16_131 VGND VGND VPWR VPWR sky130_fd_sc_hd__decap_3
XFILLER_91_557 VGND VGND VPWR VPWR sky130_fd_sc_hd__decap_3
XTAP_TAPCELL_ROW_106_1522 VGND VPWR sky130_fd_sc_hd__tapvpwrvgnd_1
XFILLER_16_153 VGND VGND VPWR VPWR sky130_fd_sc_hd__decap_3
XFILLER_32_602 VGND VGND VPWR VPWR sky130_fd_sc_hd__decap_3
XFILLER_44_462 VGND VGND VPWR VPWR sky130_fd_sc_hd__decap_3
XFILLER_16_186 VGND VGND VPWR VPWR sky130_fd_sc_hd__decap_3
XFILLER_16_197 VGND VGND VPWR VPWR sky130_fd_sc_hd__decap_3
XFILLER_31_134 VGND VGND VPWR VPWR sky130_fd_sc_hd__decap_3
XFILLER_71_270 VGND VGND VPWR VPWR sky130_fd_sc_hd__decap_3
XFILLER_31_167 VGND VGND VPWR VPWR sky130_fd_sc_hd__fill_1
XFILLER_82_6 VGND VGND VPWR VPWR sky130_fd_sc_hd__decap_3
XFILLER_8_330 VGND VGND VPWR VPWR sky130_fd_sc_hd__decap_3
X_4410_ _4411_/A _4411_/B VGND VGND VPWR VPWR _4788_/B sky130_fd_sc_hd__nor2_2
X_5390_ _5390_/A0 _4932_/X _5398_/S VGND VGND VPWR VPWR _7138_/D sky130_fd_sc_hd__mux2_2
XFILLER_113_423 VGND VGND VPWR VPWR sky130_fd_sc_hd__decap_3
X_4341_ _7255_/Q _3358_/X _4348_/B1 _7127_/Q _4340_/X VGND VGND VPWR VPWR _4365_/A
+ sky130_fd_sc_hd__a221o_2
XFILLER_99_635 VGND VGND VPWR VPWR sky130_fd_sc_hd__decap_3
X_7060_ clkload5/A _7060_/D _6340_/Y VGND VGND VPWR VPWR _7060_/Q sky130_fd_sc_hd__dfrtp_2
X_4272_ _4394_/A _4337_/B _4271_/X VGND VGND VPWR VPWR _4273_/D sky130_fd_sc_hd__or3b_2
XFILLER_99_668 VGND VGND VPWR VPWR sky130_fd_sc_hd__decap_3
XFILLER_101_607 VGND VGND VPWR VPWR sky130_fd_sc_hd__decap_3
XFILLER_101_629 VGND VGND VPWR VPWR sky130_fd_sc_hd__decap_3
XFILLER_113_478 VGND VGND VPWR VPWR sky130_fd_sc_hd__decap_3
XFILLER_100_117 VGND VGND VPWR VPWR sky130_fd_sc_hd__decap_3
XFILLER_67_532 VGND VGND VPWR VPWR sky130_fd_sc_hd__decap_3
XFILLER_79_381 VGND VGND VPWR VPWR sky130_fd_sc_hd__decap_3
XFILLER_27_407 VGND VGND VPWR VPWR sky130_fd_sc_hd__decap_3
XFILLER_39_256 VGND VGND VPWR VPWR sky130_fd_sc_hd__fill_1
XFILLER_67_576 VGND VGND VPWR VPWR sky130_fd_sc_hd__decap_3
XFILLER_94_351 VGND VGND VPWR VPWR sky130_fd_sc_hd__fill_1
XFILLER_39_278 VGND VGND VPWR VPWR sky130_fd_sc_hd__fill_2
XFILLER_54_215 VGND VGND VPWR VPWR sky130_fd_sc_hd__decap_3
XFILLER_54_248 VGND VGND VPWR VPWR sky130_fd_sc_hd__decap_3
XFILLER_54_259 VGND VGND VPWR VPWR sky130_fd_sc_hd__decap_3
XFILLER_82_568 VGND VGND VPWR VPWR sky130_fd_sc_hd__decap_3
X_6913_ _7383_/CLK _6913_/D VGND VGND VPWR VPWR _6913_/Q sky130_fd_sc_hd__dfxtp_2
XFILLER_22_112 VGND VGND VPWR VPWR sky130_fd_sc_hd__fill_2
XFILLER_50_410 VGND VGND VPWR VPWR sky130_fd_sc_hd__decap_3
XFILLER_50_421 VGND VGND VPWR VPWR sky130_fd_sc_hd__fill_2
XFILLER_50_432 VGND VGND VPWR VPWR sky130_fd_sc_hd__decap_3
X_6844_ _6909_/CLK _6844_/D VGND VGND VPWR VPWR _6844_/Q sky130_fd_sc_hd__dfxtp_2
XTAP_TAPCELL_ROW_81_1227 VGND VPWR sky130_fd_sc_hd__tapvpwrvgnd_1
XFILLER_22_156 VGND VGND VPWR VPWR sky130_fd_sc_hd__decap_3
X_6775_ _6968_/CLK _6775_/D VGND VGND VPWR VPWR _6775_/Q sky130_fd_sc_hd__dfxtp_2
X_3987_ _7347_/Q _4528_/A _3989_/S VGND VGND VPWR VPWR _7347_/D sky130_fd_sc_hd__mux2_2
XTAP_TAPCELL_ROW_33_652 VGND VPWR sky130_fd_sc_hd__tapvpwrvgnd_1
XFILLER_10_318 VGND VGND VPWR VPWR sky130_fd_sc_hd__decap_3
XFILLER_22_189 VGND VGND VPWR VPWR sky130_fd_sc_hd__decap_3
XFILLER_31_690 VGND VGND VPWR VPWR sky130_fd_sc_hd__fill_2
XTAP_TAPCELL_ROW_61_983 VGND VPWR sky130_fd_sc_hd__tapvpwrvgnd_1
XFILLER_108_217 VGND VGND VPWR VPWR sky130_fd_sc_hd__decap_3
X_5657_ _5657_/A _5657_/B _5657_/C _5657_/D VGND VGND VPWR VPWR _5664_/C sky130_fd_sc_hd__nor4_2
X_4608_ _4938_/A _4608_/B VGND VGND VPWR VPWR _4608_/Y sky130_fd_sc_hd__nor2_2
XFILLER_2_528 VGND VGND VPWR VPWR sky130_fd_sc_hd__decap_3
X_7327_ _7359_/CLK _7327_/D _6607_/Y VGND VGND VPWR VPWR _7327_/Q sky130_fd_sc_hd__dfrtp_2
XFILLER_104_445 VGND VGND VPWR VPWR sky130_fd_sc_hd__decap_3
XFILLER_77_27 VGND VGND VPWR VPWR sky130_fd_sc_hd__fill_1
XFILLER_89_145 VGND VGND VPWR VPWR sky130_fd_sc_hd__decap_3
X_7258_ _7258_/CLK _7258_/D _6538_/Y VGND VGND VPWR VPWR _7258_/Q sky130_fd_sc_hd__dfrtp_2
XTAP_TAPCELL_ROW_92_1356 VGND VPWR sky130_fd_sc_hd__tapvpwrvgnd_1
XFILLER_77_49 VGND VGND VPWR VPWR sky130_fd_sc_hd__decap_3
XFILLER_89_167 VGND VGND VPWR VPWR sky130_fd_sc_hd__fill_1
XTAP_TAPCELL_ROW_5_311 VGND VPWR sky130_fd_sc_hd__tapvpwrvgnd_1
X_7189_ clkload9/A _7189_/D _6469_/Y VGND VGND VPWR VPWR _7189_/Q sky130_fd_sc_hd__dfrtp_2
XFILLER_100_640 VGND VGND VPWR VPWR sky130_fd_sc_hd__decap_3
XFILLER_73_502 VGND VGND VPWR VPWR sky130_fd_sc_hd__fill_2
XFILLER_93_15 VGND VGND VPWR VPWR sky130_fd_sc_hd__decap_3
Xhold1030 _7404_/Q VGND VGND VPWR VPWR _3684_/A1 sky130_fd_sc_hd__dlygate4sd3_1
Xhold1041 _7388_/Q VGND VGND VPWR VPWR _3833_/A0 sky130_fd_sc_hd__dlygate4sd3_1
XFILLER_73_535 VGND VGND VPWR VPWR sky130_fd_sc_hd__decap_3
XFILLER_93_37 VGND VGND VPWR VPWR sky130_fd_sc_hd__decap_3
Xhold1052 _7266_/Q VGND VGND VPWR VPWR _4933_/A0 sky130_fd_sc_hd__dlygate4sd3_1
Xhold1063 _7243_/Q VGND VGND VPWR VPWR _5169_/A sky130_fd_sc_hd__dlygate4sd3_1
Xhold1074 _4505_/X VGND VGND VPWR VPWR _7327_/D sky130_fd_sc_hd__dlygate4sd3_1
Xhold1085 _7242_/Q VGND VGND VPWR VPWR _5171_/A sky130_fd_sc_hd__dlygate4sd3_1
Xhold1096 _7308_/Q VGND VGND VPWR VPWR _4544_/A sky130_fd_sc_hd__dlygate4sd3_1
XFILLER_14_613 VGND VGND VPWR VPWR sky130_fd_sc_hd__fill_1
XFILLER_26_64 VGND VGND VPWR VPWR sky130_fd_sc_hd__decap_3
XFILLER_60_229 VGND VGND VPWR VPWR sky130_fd_sc_hd__decap_3
Xclkbuf_3_6__f_clk clkbuf_0_clk/X VGND VGND VPWR VPWR clkbuf_3_6__f_clk/X sky130_fd_sc_hd__clkbuf_16
XFILLER_53_281 VGND VGND VPWR VPWR sky130_fd_sc_hd__decap_3
XFILLER_13_134 VGND VGND VPWR VPWR sky130_fd_sc_hd__decap_3
XFILLER_9_116 VGND VGND VPWR VPWR sky130_fd_sc_hd__decap_3
XFILLER_13_178 VGND VGND VPWR VPWR sky130_fd_sc_hd__decap_3
XFILLER_41_498 VGND VGND VPWR VPWR sky130_fd_sc_hd__decap_3
XTAP_TAPCELL_ROW_101_1463 VGND VPWR sky130_fd_sc_hd__tapvpwrvgnd_1
XFILLER_9_149 VGND VGND VPWR VPWR sky130_fd_sc_hd__decap_3
XFILLER_42_74 VGND VGND VPWR VPWR sky130_fd_sc_hd__fill_1
XFILLER_42_85 VGND VGND VPWR VPWR sky130_fd_sc_hd__decap_3
XFILLER_5_311 VGND VGND VPWR VPWR sky130_fd_sc_hd__decap_3
XTAP_TAPCELL_ROW_11_379 VGND VPWR sky130_fd_sc_hd__tapvpwrvgnd_1
XFILLER_5_355 VGND VGND VPWR VPWR sky130_fd_sc_hd__decap_3
XFILLER_107_272 VGND VGND VPWR VPWR sky130_fd_sc_hd__decap_3
XFILLER_5_388 VGND VGND VPWR VPWR sky130_fd_sc_hd__decap_3
XFILLER_107_294 VGND VGND VPWR VPWR sky130_fd_sc_hd__fill_1
XFILLER_47_9 VGND VGND VPWR VPWR sky130_fd_sc_hd__decap_3
XFILLER_110_404 VGND VGND VPWR VPWR sky130_fd_sc_hd__decap_3
XFILLER_3_24 VGND VGND VPWR VPWR sky130_fd_sc_hd__decap_3
XFILLER_3_35 VGND VGND VPWR VPWR sky130_fd_sc_hd__decap_3
XFILLER_68_318 VGND VGND VPWR VPWR sky130_fd_sc_hd__decap_3
XFILLER_95_104 VGND VGND VPWR VPWR sky130_fd_sc_hd__decap_3
XFILLER_96_616 VGND VGND VPWR VPWR sky130_fd_sc_hd__decap_3
XFILLER_110_448 VGND VGND VPWR VPWR sky130_fd_sc_hd__decap_3
XFILLER_95_148 VGND VGND VPWR VPWR sky130_fd_sc_hd__decap_3
XTAP_TAPCELL_ROW_112_1592 VGND VPWR sky130_fd_sc_hd__tapvpwrvgnd_1
XFILLER_67_93 VGND VGND VPWR VPWR sky130_fd_sc_hd__decap_3
XFILLER_64_513 VGND VGND VPWR VPWR sky130_fd_sc_hd__decap_3
XFILLER_76_395 VGND VGND VPWR VPWR sky130_fd_sc_hd__decap_3
XFILLER_17_440 VGND VGND VPWR VPWR sky130_fd_sc_hd__decap_3
XFILLER_36_248 VGND VGND VPWR VPWR sky130_fd_sc_hd__decap_3
XFILLER_64_557 VGND VGND VPWR VPWR sky130_fd_sc_hd__decap_3
XFILLER_91_332 VGND VGND VPWR VPWR sky130_fd_sc_hd__decap_3
XFILLER_91_343 VGND VGND VPWR VPWR sky130_fd_sc_hd__decap_3
XFILLER_51_218 VGND VGND VPWR VPWR sky130_fd_sc_hd__decap_3
XFILLER_91_376 VGND VGND VPWR VPWR sky130_fd_sc_hd__decap_3
XTAP_TAPCELL_ROW_67_1060 VGND VPWR sky130_fd_sc_hd__tapvpwrvgnd_1
XTAP_TAPCELL_ROW_19_479 VGND VPWR sky130_fd_sc_hd__tapvpwrvgnd_1
XFILLER_32_421 VGND VGND VPWR VPWR sky130_fd_sc_hd__decap_3
XFILLER_83_92 VGND VGND VPWR VPWR sky130_fd_sc_hd__decap_3
X_4890_ _5101_/A _4890_/B VGND VGND VPWR VPWR _4890_/Y sky130_fd_sc_hd__nor2_2
X_3910_ _6916_/Q _3912_/A2 _3913_/A2 _6780_/Q VGND VGND VPWR VPWR _3910_/X sky130_fd_sc_hd__a22o_2
X_3841_ _6845_/Q _3852_/A2 _5660_/B _6830_/Q _3840_/X VGND VGND VPWR VPWR _3841_/X
+ sky130_fd_sc_hd__a221o_2
XFILLER_32_487 VGND VGND VPWR VPWR sky130_fd_sc_hd__fill_1
XFILLER_80_3 VGND VGND VPWR VPWR sky130_fd_sc_hd__decap_3
X_6560_ _6634_/A VGND VGND VPWR VPWR _6560_/Y sky130_fd_sc_hd__inv_2
X_3772_ _6854_/Q _3913_/B1 _3912_/B1 _6902_/Q _3771_/X VGND VGND VPWR VPWR _3772_/X
+ sky130_fd_sc_hd__a221o_2
XTAP_TAPCELL_ROW_30_611 VGND VPWR sky130_fd_sc_hd__tapvpwrvgnd_1
XFILLER_8_171 VGND VGND VPWR VPWR sky130_fd_sc_hd__decap_3
X_6491_ _6578_/A VGND VGND VPWR VPWR _6491_/Y sky130_fd_sc_hd__inv_2
X_5373_ _5373_/A0 _4792_/X _5383_/S VGND VGND VPWR VPWR _7146_/D sky130_fd_sc_hd__mux2_2
X_7112_ _7361_/CLK _7112_/D _6392_/Y VGND VGND VPWR VPWR _7112_/Q sky130_fd_sc_hd__dfrtp_2
Xoutput468 _5658_/B VGND VGND VPWR VPWR alu_result_out[12] sky130_fd_sc_hd__clkdlybuf4s25_1
X_4324_ _7039_/Q _4510_/S _4354_/B1 _7386_/Q VGND VGND VPWR VPWR _4324_/X sky130_fd_sc_hd__a22o_2
XFILLER_99_432 VGND VGND VPWR VPWR sky130_fd_sc_hd__decap_3
XFILLER_101_415 VGND VGND VPWR VPWR sky130_fd_sc_hd__decap_3
X_7043_ _7401_/CLK _7043_/D _6323_/Y VGND VGND VPWR VPWR _7043_/Q sky130_fd_sc_hd__dfrtp_2
Xoutput479 _5663_/C VGND VGND VPWR VPWR alu_result_out[22] sky130_fd_sc_hd__clkdlybuf4s25_1
XFILLER_99_476 VGND VGND VPWR VPWR sky130_fd_sc_hd__decap_3
XFILLER_86_115 VGND VGND VPWR VPWR sky130_fd_sc_hd__decap_3
X_4255_ _4251_/X _4254_/X _4327_/A VGND VGND VPWR VPWR _4256_/C sky130_fd_sc_hd__o21ai_2
XFILLER_67_340 VGND VGND VPWR VPWR sky130_fd_sc_hd__decap_3
XFILLER_95_660 VGND VGND VPWR VPWR sky130_fd_sc_hd__fill_1
X_4186_ _4186_/A _4636_/B VGND VGND VPWR VPWR _4186_/Y sky130_fd_sc_hd__xnor2_2
XFILLER_27_215 VGND VGND VPWR VPWR sky130_fd_sc_hd__decap_3
XFILLER_95_682 VGND VGND VPWR VPWR sky130_fd_sc_hd__fill_2
XTAP_TAPCELL_ROW_38_711 VGND VPWR sky130_fd_sc_hd__tapvpwrvgnd_1
XFILLER_82_343 VGND VGND VPWR VPWR sky130_fd_sc_hd__decap_3
XFILLER_94_192 VGND VGND VPWR VPWR sky130_fd_sc_hd__decap_3
XFILLER_103_69 VGND VGND VPWR VPWR sky130_fd_sc_hd__decap_3
XFILLER_70_505 VGND VGND VPWR VPWR sky130_fd_sc_hd__decap_3
XFILLER_82_376 VGND VGND VPWR VPWR sky130_fd_sc_hd__decap_3
XFILLER_35_281 VGND VGND VPWR VPWR sky130_fd_sc_hd__decap_3
XFILLER_63_590 VGND VGND VPWR VPWR sky130_fd_sc_hd__decap_3
X_6827_ _6967_/CLK _6827_/D VGND VGND VPWR VPWR _6827_/Q sky130_fd_sc_hd__dfxtp_2
XFILLER_10_137 VGND VGND VPWR VPWR sky130_fd_sc_hd__decap_3
X_6758_ _6965_/CLK _6758_/D VGND VGND VPWR VPWR _6758_/Q sky130_fd_sc_hd__dfxtp_2
XFILLER_109_526 VGND VGND VPWR VPWR sky130_fd_sc_hd__decap_3
XFILLER_12_44 VGND VGND VPWR VPWR sky130_fd_sc_hd__decap_3
X_6689_ _7384_/CLK _6689_/D VGND VGND VPWR VPWR _6689_/Q sky130_fd_sc_hd__dfxtp_2
XFILLER_12_88 VGND VGND VPWR VPWR sky130_fd_sc_hd__decap_3
XFILLER_88_15 VGND VGND VPWR VPWR sky130_fd_sc_hd__decap_3
XFILLER_104_231 VGND VGND VPWR VPWR sky130_fd_sc_hd__decap_3
XFILLER_2_336 VGND VGND VPWR VPWR sky130_fd_sc_hd__decap_3
XFILLER_88_48 VGND VGND VPWR VPWR sky130_fd_sc_hd__fill_1
XFILLER_77_104 VGND VGND VPWR VPWR sky130_fd_sc_hd__decap_3
XFILLER_78_616 VGND VGND VPWR VPWR sky130_fd_sc_hd__decap_3
XFILLER_77_126 VGND VGND VPWR VPWR sky130_fd_sc_hd__decap_3
XFILLER_37_30 VGND VGND VPWR VPWR sky130_fd_sc_hd__decap_3
XFILLER_73_310 VGND VGND VPWR VPWR sky130_fd_sc_hd__decap_3
XFILLER_92_118 VGND VGND VPWR VPWR sky130_fd_sc_hd__decap_3
XFILLER_100_492 VGND VGND VPWR VPWR sky130_fd_sc_hd__fill_2
XFILLER_18_259 VGND VGND VPWR VPWR sky130_fd_sc_hd__decap_3
XFILLER_37_52 VGND VGND VPWR VPWR sky130_fd_sc_hd__decap_3
XFILLER_37_63 VGND VGND VPWR VPWR sky130_fd_sc_hd__decap_3
XFILLER_73_343 VGND VGND VPWR VPWR sky130_fd_sc_hd__decap_3
XFILLER_61_505 VGND VGND VPWR VPWR sky130_fd_sc_hd__decap_3
XFILLER_26_281 VGND VGND VPWR VPWR sky130_fd_sc_hd__decap_3
XTAP_TAPCELL_ROW_16_438 VGND VPWR sky130_fd_sc_hd__tapvpwrvgnd_1
XFILLER_53_51 VGND VGND VPWR VPWR sky130_fd_sc_hd__decap_3
XTAP_TAPCELL_ROW_16_449 VGND VPWR sky130_fd_sc_hd__tapvpwrvgnd_1
XFILLER_41_262 VGND VGND VPWR VPWR sky130_fd_sc_hd__decap_3
XFILLER_41_284 VGND VGND VPWR VPWR sky130_fd_sc_hd__decap_3
XFILLER_53_84 VGND VGND VPWR VPWR sky130_fd_sc_hd__decap_3
XFILLER_5_152 VGND VGND VPWR VPWR sky130_fd_sc_hd__decap_3
XTAP_TAPCELL_ROW_114_1621 VGND VPWR sky130_fd_sc_hd__tapvpwrvgnd_1
XFILLER_108_592 VGND VGND VPWR VPWR sky130_fd_sc_hd__decap_3
XFILLER_5_196 VGND VGND VPWR VPWR sky130_fd_sc_hd__decap_3
XFILLER_96_424 VGND VGND VPWR VPWR sky130_fd_sc_hd__decap_3
XFILLER_110_234 VGND VGND VPWR VPWR sky130_fd_sc_hd__decap_3
XFILLER_110_245 VGND VGND VPWR VPWR sky130_fd_sc_hd__decap_3
XFILLER_49_340 VGND VGND VPWR VPWR sky130_fd_sc_hd__decap_3
XFILLER_77_660 VGND VGND VPWR VPWR sky130_fd_sc_hd__fill_1
XFILLER_96_468 VGND VGND VPWR VPWR sky130_fd_sc_hd__decap_3
X_4040_ _4608_/B _4040_/B VGND VGND VPWR VPWR _4040_/Y sky130_fd_sc_hd__nor2_2
XFILLER_110_289 VGND VGND VPWR VPWR sky130_fd_sc_hd__decap_3
XFILLER_49_373 VGND VGND VPWR VPWR sky130_fd_sc_hd__decap_3
XFILLER_83_107 VGND VGND VPWR VPWR sky130_fd_sc_hd__decap_3
XFILLER_64_321 VGND VGND VPWR VPWR sky130_fd_sc_hd__decap_3
XFILLER_76_192 VGND VGND VPWR VPWR sky130_fd_sc_hd__decap_3
XFILLER_24_218 VGND VGND VPWR VPWR sky130_fd_sc_hd__decap_3
XFILLER_64_354 VGND VGND VPWR VPWR sky130_fd_sc_hd__decap_3
XFILLER_64_365 VGND VGND VPWR VPWR sky130_fd_sc_hd__decap_3
XFILLER_91_162 VGND VGND VPWR VPWR sky130_fd_sc_hd__decap_3
XFILLER_94_91 VGND VGND VPWR VPWR sky130_fd_sc_hd__decap_3
XFILLER_91_195 VGND VGND VPWR VPWR sky130_fd_sc_hd__decap_3
X_4942_ _6995_/Q _4960_/B _4677_/B _5129_/B VGND VGND VPWR VPWR _4943_/B sky130_fd_sc_hd__o211ai_2
XFILLER_20_424 VGND VGND VPWR VPWR sky130_fd_sc_hd__decap_3
XFILLER_32_273 VGND VGND VPWR VPWR sky130_fd_sc_hd__fill_1
X_6612_ _6644_/A VGND VGND VPWR VPWR _6612_/Y sky130_fd_sc_hd__inv_2
X_4873_ _4764_/B _4111_/B _4845_/A _5101_/A VGND VGND VPWR VPWR _4873_/X sky130_fd_sc_hd__o22a_2
XFILLER_32_295 VGND VGND VPWR VPWR sky130_fd_sc_hd__decap_3
X_3824_ _6965_/Q _3869_/A2 _3825_/B1 _6953_/Q _3823_/X VGND VGND VPWR VPWR _3824_/X
+ sky130_fd_sc_hd__a221o_2
X_6543_ _6548_/A VGND VGND VPWR VPWR _6543_/Y sky130_fd_sc_hd__inv_2
X_3755_ _6934_/Q _3859_/A2 _3858_/B1 _6886_/Q VGND VGND VPWR VPWR _3755_/X sky130_fd_sc_hd__a22o_2
X_6474_ _6638_/A VGND VGND VPWR VPWR _6474_/Y sky130_fd_sc_hd__inv_2
XFILLER_106_529 VGND VGND VPWR VPWR sky130_fd_sc_hd__decap_3
X_5425_ _5425_/A0 _3993_/X _5429_/S VGND VGND VPWR VPWR _7121_/D sky130_fd_sc_hd__mux2_2
XPHY_EDGE_ROW_12_Right_12 VGND VGND VPWR VPWR sky130_fd_sc_hd__decap_3
XTAP_TAPCELL_ROW_76_1159 VGND VPWR sky130_fd_sc_hd__tapvpwrvgnd_1
XFILLER_58_18 VGND VGND VPWR VPWR sky130_fd_sc_hd__fill_1
XFILLER_58_29 VGND VGND VPWR VPWR sky130_fd_sc_hd__decap_3
XFILLER_87_402 VGND VGND VPWR VPWR sky130_fd_sc_hd__decap_3
X_5356_ _5356_/A0 _3993_/X _5360_/S VGND VGND VPWR VPWR _7153_/D sky130_fd_sc_hd__mux2_2
XFILLER_99_240 VGND VGND VPWR VPWR sky130_fd_sc_hd__decap_3
XFILLER_101_201 VGND VGND VPWR VPWR sky130_fd_sc_hd__decap_3
XFILLER_114_584 VGND VGND VPWR VPWR sky130_fd_sc_hd__decap_3
XFILLER_59_137 VGND VGND VPWR VPWR sky130_fd_sc_hd__decap_3
XFILLER_87_446 VGND VGND VPWR VPWR sky130_fd_sc_hd__fill_2
X_4307_ _7224_/Q _4307_/A2 _4522_/S _7037_/Q VGND VGND VPWR VPWR _4307_/X sky130_fd_sc_hd__a22o_2
XFILLER_99_284 VGND VGND VPWR VPWR sky130_fd_sc_hd__decap_3
XFILLER_99_273 VGND VGND VPWR VPWR sky130_fd_sc_hd__decap_3
XFILLER_101_234 VGND VGND VPWR VPWR sky130_fd_sc_hd__decap_3
XFILLER_59_159 VGND VGND VPWR VPWR sky130_fd_sc_hd__decap_3
X_7026_ _7371_/CLK _7026_/D _6306_/Y VGND VGND VPWR VPWR _7026_/Q sky130_fd_sc_hd__dfrtp_2
X_4238_ _7067_/Q _4305_/B _4460_/A _4237_/X VGND VGND VPWR VPWR _4629_/B sky130_fd_sc_hd__o211ai_2
XFILLER_101_267 VGND VGND VPWR VPWR sky130_fd_sc_hd__fill_1
XFILLER_114_46 VGND VGND VPWR VPWR sky130_fd_sc_hd__decap_3
XFILLER_68_660 VGND VGND VPWR VPWR sky130_fd_sc_hd__fill_2
XFILLER_74_118 VGND VGND VPWR VPWR sky130_fd_sc_hd__decap_3
XFILLER_114_68 VGND VGND VPWR VPWR sky130_fd_sc_hd__decap_3
XFILLER_83_652 VGND VGND VPWR VPWR sky130_fd_sc_hd__decap_3
X_4169_ _4165_/X _4168_/X _4425_/A VGND VGND VPWR VPWR _4202_/A sky130_fd_sc_hd__o21a_2
XFILLER_55_376 VGND VGND VPWR VPWR sky130_fd_sc_hd__decap_3
XFILLER_82_162 VGND VGND VPWR VPWR sky130_fd_sc_hd__decap_3
XPHY_EDGE_ROW_21_Right_21 VGND VGND VPWR VPWR sky130_fd_sc_hd__decap_3
XFILLER_70_335 VGND VGND VPWR VPWR sky130_fd_sc_hd__decap_3
XTAP_TAPCELL_ROW_87_1299 VGND VPWR sky130_fd_sc_hd__tapvpwrvgnd_1
XFILLER_70_368 VGND VGND VPWR VPWR sky130_fd_sc_hd__decap_3
XFILLER_11_402 VGND VGND VPWR VPWR sky130_fd_sc_hd__fill_1
XFILLER_23_21 VGND VGND VPWR VPWR sky130_fd_sc_hd__decap_3
XFILLER_23_251 VGND VGND VPWR VPWR sky130_fd_sc_hd__decap_3
XFILLER_90_38 VGND VGND VPWR VPWR sky130_fd_sc_hd__decap_3
XTAP_TAPCELL_ROW_41_739 VGND VPWR sky130_fd_sc_hd__tapvpwrvgnd_1
XTAP_TAPCELL_ROW_13_408 VGND VPWR sky130_fd_sc_hd__tapvpwrvgnd_1
XFILLER_11_457 VGND VGND VPWR VPWR sky130_fd_sc_hd__decap_3
XFILLER_109_301 VGND VGND VPWR VPWR sky130_fd_sc_hd__decap_3
XFILLER_109_334 VGND VGND VPWR VPWR sky130_fd_sc_hd__fill_2
XPHY_EDGE_ROW_30_Right_30 VGND VGND VPWR VPWR sky130_fd_sc_hd__decap_3
XFILLER_99_25 VGND VGND VPWR VPWR sky130_fd_sc_hd__decap_3
XFILLER_109_367 VGND VGND VPWR VPWR sky130_fd_sc_hd__decap_3
XFILLER_99_69 VGND VGND VPWR VPWR sky130_fd_sc_hd__decap_3
XFILLER_2_111 VGND VGND VPWR VPWR sky130_fd_sc_hd__decap_3
XFILLER_105_551 VGND VGND VPWR VPWR sky130_fd_sc_hd__decap_3
XFILLER_2_133 VGND VGND VPWR VPWR sky130_fd_sc_hd__decap_3
XFILLER_2_144 VGND VGND VPWR VPWR sky130_fd_sc_hd__decap_3
XFILLER_78_446 VGND VGND VPWR VPWR sky130_fd_sc_hd__decap_3
XFILLER_93_405 VGND VGND VPWR VPWR sky130_fd_sc_hd__decap_3
XFILLER_65_107 VGND VGND VPWR VPWR sky130_fd_sc_hd__decap_3
XTAP_TAPCELL_ROW_49_839 VGND VPWR sky130_fd_sc_hd__tapvpwrvgnd_1
XFILLER_19_535 VGND VGND VPWR VPWR sky130_fd_sc_hd__fill_2
XFILLER_46_321 VGND VGND VPWR VPWR sky130_fd_sc_hd__decap_3
XFILLER_93_449 VGND VGND VPWR VPWR sky130_fd_sc_hd__decap_3
XFILLER_34_505 VGND VGND VPWR VPWR sky130_fd_sc_hd__decap_3
XFILLER_46_354 VGND VGND VPWR VPWR sky130_fd_sc_hd__decap_3
XFILLER_46_365 VGND VGND VPWR VPWR sky130_fd_sc_hd__decap_3
XFILLER_34_527 VGND VGND VPWR VPWR sky130_fd_sc_hd__decap_3
XFILLER_46_398 VGND VGND VPWR VPWR sky130_fd_sc_hd__decap_3
XFILLER_61_324 VGND VGND VPWR VPWR sky130_fd_sc_hd__decap_3
XFILLER_64_72 VGND VGND VPWR VPWR sky130_fd_sc_hd__decap_3
XFILLER_73_184 VGND VGND VPWR VPWR sky130_fd_sc_hd__decap_3
XTAP_TAPCELL_ROW_29_596 VGND VPWR sky130_fd_sc_hd__tapvpwrvgnd_1
XFILLER_14_240 VGND VGND VPWR VPWR sky130_fd_sc_hd__decap_3
XFILLER_61_346 VGND VGND VPWR VPWR sky130_fd_sc_hd__decap_3
XFILLER_64_83 VGND VGND VPWR VPWR sky130_fd_sc_hd__fill_1
XFILLER_14_262 VGND VGND VPWR VPWR sky130_fd_sc_hd__decap_3
XFILLER_9_34 VGND VGND VPWR VPWR sky130_fd_sc_hd__decap_3
X_3540_ _3502_/A _3502_/B _3485_/C VGND VGND VPWR VPWR _3540_/X sky130_fd_sc_hd__o21a_2
Xhold907 _7087_/Q VGND VGND VPWR VPWR _7087_/D sky130_fd_sc_hd__dlygate4sd3_1
Xhold918 _6698_/Q VGND VGND VPWR VPWR hold918/X sky130_fd_sc_hd__dlygate4sd3_1
XFILLER_115_326 VGND VGND VPWR VPWR sky130_fd_sc_hd__decap_3
XFILLER_115_337 VGND VGND VPWR VPWR sky130_fd_sc_hd__fill_1
XFILLER_6_494 VGND VGND VPWR VPWR sky130_fd_sc_hd__decap_3
Xhold929 _6688_/Q VGND VGND VPWR VPWR hold929/X sky130_fd_sc_hd__dlygate4sd3_1
X_3471_ _3545_/A _3545_/B VGND VGND VPWR VPWR _3505_/A sky130_fd_sc_hd__and2b_2
XFILLER_115_359 VGND VGND VPWR VPWR sky130_fd_sc_hd__fill_1
XFILLER_43_3 VGND VGND VPWR VPWR sky130_fd_sc_hd__fill_1
XFILLER_69_402 VGND VGND VPWR VPWR sky130_fd_sc_hd__decap_3
XFILLER_69_435 VGND VGND VPWR VPWR sky130_fd_sc_hd__decap_3
XFILLER_96_221 VGND VGND VPWR VPWR sky130_fd_sc_hd__decap_3
XFILLER_111_532 VGND VGND VPWR VPWR sky130_fd_sc_hd__fill_1
XFILLER_111_554 VGND VGND VPWR VPWR sky130_fd_sc_hd__decap_3
XFILLER_96_243 VGND VGND VPWR VPWR sky130_fd_sc_hd__decap_3
X_5072_ _5114_/A _5072_/B _5072_/C VGND VGND VPWR VPWR _5075_/B sky130_fd_sc_hd__and3_2
XFILLER_111_587 VGND VGND VPWR VPWR sky130_fd_sc_hd__fill_1
XFILLER_84_427 VGND VGND VPWR VPWR sky130_fd_sc_hd__fill_2
XFILLER_96_265 VGND VGND VPWR VPWR sky130_fd_sc_hd__decap_3
XFILLER_49_181 VGND VGND VPWR VPWR sky130_fd_sc_hd__decap_3
XFILLER_77_490 VGND VGND VPWR VPWR sky130_fd_sc_hd__decap_3
XFILLER_96_298 VGND VGND VPWR VPWR sky130_fd_sc_hd__decap_3
XFILLER_25_516 VGND VGND VPWR VPWR sky130_fd_sc_hd__fill_2
XFILLER_37_376 VGND VGND VPWR VPWR sky130_fd_sc_hd__fill_1
XFILLER_25_538 VGND VGND VPWR VPWR sky130_fd_sc_hd__fill_1
XFILLER_52_302 VGND VGND VPWR VPWR sky130_fd_sc_hd__decap_3
XFILLER_52_324 VGND VGND VPWR VPWR sky130_fd_sc_hd__decap_3
XFILLER_52_357 VGND VGND VPWR VPWR sky130_fd_sc_hd__decap_3
XFILLER_52_368 VGND VGND VPWR VPWR sky130_fd_sc_hd__decap_3
XFILLER_80_655 VGND VGND VPWR VPWR sky130_fd_sc_hd__decap_3
XFILLER_100_26 VGND VGND VPWR VPWR sky130_fd_sc_hd__fill_2
X_4925_ _4764_/B _4158_/A _4920_/A _5101_/A _4924_/X VGND VGND VPWR VPWR _4925_/X
+ sky130_fd_sc_hd__o221a_2
XFILLER_20_221 VGND VGND VPWR VPWR sky130_fd_sc_hd__fill_1
X_3807_ _6703_/Q _3906_/B1 _3847_/B1 _6881_/Q VGND VGND VPWR VPWR _3807_/X sky130_fd_sc_hd__a22o_2
XFILLER_20_298 VGND VGND VPWR VPWR sky130_fd_sc_hd__decap_3
X_6526_ _6647_/A VGND VGND VPWR VPWR _6526_/Y sky130_fd_sc_hd__inv_2
X_4787_ _4787_/A _4787_/B VGND VGND VPWR VPWR _4787_/Y sky130_fd_sc_hd__xnor2_2
XFILLER_106_315 VGND VGND VPWR VPWR sky130_fd_sc_hd__decap_3
XFILLER_109_46 VGND VGND VPWR VPWR sky130_fd_sc_hd__decap_3
X_3738_ _6740_/Q _3913_/A2 _3913_/B1 _6734_/Q _3737_/X VGND VGND VPWR VPWR _3738_/X
+ sky130_fd_sc_hd__a221o_2
XFILLER_106_348 VGND VGND VPWR VPWR sky130_fd_sc_hd__decap_3
XFILLER_109_57 VGND VGND VPWR VPWR sky130_fd_sc_hd__decap_3
X_6457_ _6584_/A VGND VGND VPWR VPWR _6457_/Y sky130_fd_sc_hd__inv_2
X_3669_ _6807_/Q _3825_/B1 _3826_/A2 _6717_/Q _3668_/X VGND VGND VPWR VPWR _3669_/X
+ sky130_fd_sc_hd__a221o_2
X_6388_ _6388_/A VGND VGND VPWR VPWR _6388_/Y sky130_fd_sc_hd__inv_2
XFILLER_87_221 VGND VGND VPWR VPWR sky130_fd_sc_hd__decap_3
XFILLER_87_232 VGND VGND VPWR VPWR sky130_fd_sc_hd__decap_3
XFILLER_47_107 VGND VGND VPWR VPWR sky130_fd_sc_hd__decap_3
XFILLER_75_405 VGND VGND VPWR VPWR sky130_fd_sc_hd__fill_1
XFILLER_75_427 VGND VGND VPWR VPWR sky130_fd_sc_hd__decap_3
XFILLER_87_265 VGND VGND VPWR VPWR sky130_fd_sc_hd__decap_3
XFILLER_87_287 VGND VGND VPWR VPWR sky130_fd_sc_hd__decap_3
XTAP_TAPCELL_ROW_89_1317 VGND VPWR sky130_fd_sc_hd__tapvpwrvgnd_1
XFILLER_18_32 VGND VGND VPWR VPWR sky130_fd_sc_hd__decap_3
XFILLER_28_321 VGND VGND VPWR VPWR sky130_fd_sc_hd__decap_3
XFILLER_47_129 VGND VGND VPWR VPWR sky130_fd_sc_hd__decap_3
XFILLER_75_449 VGND VGND VPWR VPWR sky130_fd_sc_hd__decap_3
X_7009_ _7330_/CLK _7009_/Q _6289_/Y VGND VGND VPWR VPWR _7009_/Q sky130_fd_sc_hd__dfrtp_2
XFILLER_28_365 VGND VGND VPWR VPWR sky130_fd_sc_hd__decap_3
XFILLER_90_419 VGND VGND VPWR VPWR sky130_fd_sc_hd__fill_1
XTAP_TAPCELL_ROW_46_809 VGND VPWR sky130_fd_sc_hd__tapvpwrvgnd_1
XFILLER_43_302 VGND VGND VPWR VPWR sky130_fd_sc_hd__decap_3
XFILLER_43_324 VGND VGND VPWR VPWR sky130_fd_sc_hd__decap_3
XFILLER_71_644 VGND VGND VPWR VPWR sky130_fd_sc_hd__decap_3
XFILLER_83_482 VGND VGND VPWR VPWR sky130_fd_sc_hd__decap_3
XFILLER_31_508 VGND VGND VPWR VPWR sky130_fd_sc_hd__decap_3
XFILLER_43_346 VGND VGND VPWR VPWR sky130_fd_sc_hd__decap_3
XFILLER_55_195 VGND VGND VPWR VPWR sky130_fd_sc_hd__decap_3
XFILLER_70_187 VGND VGND VPWR VPWR sky130_fd_sc_hd__decap_3
XTAP_TAPCELL_ROW_54_897 VGND VPWR sky130_fd_sc_hd__tapvpwrvgnd_1
XTAP_TAPCELL_ROW_26_566 VGND VPWR sky130_fd_sc_hd__tapvpwrvgnd_1
XFILLER_34_97 VGND VGND VPWR VPWR sky130_fd_sc_hd__decap_3
XFILLER_11_243 VGND VGND VPWR VPWR sky130_fd_sc_hd__decap_3
XFILLER_7_214 VGND VGND VPWR VPWR sky130_fd_sc_hd__decap_3
XFILLER_11_276 VGND VGND VPWR VPWR sky130_fd_sc_hd__decap_3
XFILLER_11_287 VGND VGND VPWR VPWR sky130_fd_sc_hd__decap_3
XFILLER_7_225 VGND VGND VPWR VPWR sky130_fd_sc_hd__decap_3
XFILLER_7_247 VGND VGND VPWR VPWR sky130_fd_sc_hd__decap_3
XFILLER_50_52 VGND VGND VPWR VPWR sky130_fd_sc_hd__decap_3
XFILLER_50_85 VGND VGND VPWR VPWR sky130_fd_sc_hd__decap_3
XFILLER_3_420 VGND VGND VPWR VPWR sky130_fd_sc_hd__decap_3
XFILLER_98_519 VGND VGND VPWR VPWR sky130_fd_sc_hd__decap_3
XFILLER_112_329 VGND VGND VPWR VPWR sky130_fd_sc_hd__decap_3
XFILLER_38_118 VGND VGND VPWR VPWR sky130_fd_sc_hd__decap_3
XFILLER_66_416 VGND VGND VPWR VPWR sky130_fd_sc_hd__decap_3
XFILLER_66_427 VGND VGND VPWR VPWR sky130_fd_sc_hd__decap_3
XFILLER_19_332 VGND VGND VPWR VPWR sky130_fd_sc_hd__decap_3
XFILLER_93_246 VGND VGND VPWR VPWR sky130_fd_sc_hd__fill_1
XFILLER_19_343 VGND VGND VPWR VPWR sky130_fd_sc_hd__decap_3
XFILLER_47_652 VGND VGND VPWR VPWR sky130_fd_sc_hd__decap_3
XFILLER_75_60 VGND VGND VPWR VPWR sky130_fd_sc_hd__decap_3
XFILLER_81_408 VGND VGND VPWR VPWR sky130_fd_sc_hd__fill_2
XFILLER_93_268 VGND VGND VPWR VPWR sky130_fd_sc_hd__decap_3
XFILLER_93_279 VGND VGND VPWR VPWR sky130_fd_sc_hd__fill_1
XTAP_TAPCELL_ROW_109_1564 VGND VPWR sky130_fd_sc_hd__tapvpwrvgnd_1
XFILLER_19_387 VGND VGND VPWR VPWR sky130_fd_sc_hd__decap_3
XFILLER_46_173 VGND VGND VPWR VPWR sky130_fd_sc_hd__decap_3
XFILLER_74_493 VGND VGND VPWR VPWR sky130_fd_sc_hd__decap_3
XFILLER_34_357 VGND VGND VPWR VPWR sky130_fd_sc_hd__decap_3
XFILLER_34_368 VGND VGND VPWR VPWR sky130_fd_sc_hd__decap_3
XFILLER_61_143 VGND VGND VPWR VPWR sky130_fd_sc_hd__decap_3
XFILLER_61_187 VGND VGND VPWR VPWR sky130_fd_sc_hd__decap_3
XFILLER_30_541 VGND VGND VPWR VPWR sky130_fd_sc_hd__decap_3
XFILLER_91_92 VGND VGND VPWR VPWR sky130_fd_sc_hd__fill_1
X_5690_ _7351_/Q hold990/X _5708_/S VGND VGND VPWR VPWR _6695_/D sky130_fd_sc_hd__mux2_2
X_4710_ _7004_/Q _4801_/A VGND VGND VPWR VPWR _4775_/A sky130_fd_sc_hd__and2_2
XFILLER_30_574 VGND VGND VPWR VPWR sky130_fd_sc_hd__decap_3
X_4641_ _4920_/A _4379_/B _4640_/Y _4158_/A VGND VGND VPWR VPWR _4903_/B sky130_fd_sc_hd__o31a_2
X_7360_ _7360_/CLK _7360_/D _6640_/Y VGND VGND VPWR VPWR _7360_/Q sky130_fd_sc_hd__dfrtp_2
X_7291_ clkload2/A _7291_/D _6571_/Y VGND VGND VPWR VPWR _7291_/Q sky130_fd_sc_hd__dfrtp_2
Xhold704 _6753_/Q VGND VGND VPWR VPWR _6753_/D sky130_fd_sc_hd__dlygate4sd3_1
Xhold715 _6834_/Q VGND VGND VPWR VPWR _6834_/D sky130_fd_sc_hd__dlygate4sd3_1
Xhold726 _6954_/Q VGND VGND VPWR VPWR _6954_/D sky130_fd_sc_hd__dlygate4sd3_1
Xhold737 _6825_/Q VGND VGND VPWR VPWR _6825_/D sky130_fd_sc_hd__dlygate4sd3_1
X_6311_ _6660_/A VGND VGND VPWR VPWR _6311_/Y sky130_fd_sc_hd__inv_2
X_3523_ _3505_/A _3458_/Y _3505_/B _3506_/Y _3508_/A VGND VGND VPWR VPWR _3620_/A
+ sky130_fd_sc_hd__o311a_4
XFILLER_115_167 VGND VGND VPWR VPWR sky130_fd_sc_hd__fill_1
XFILLER_116_679 VGND VGND VPWR VPWR sky130_fd_sc_hd__decap_3
XFILLER_6_291 VGND VGND VPWR VPWR sky130_fd_sc_hd__decap_3
XFILLER_89_508 VGND VGND VPWR VPWR sky130_fd_sc_hd__decap_3
Xhold748 _6873_/Q VGND VGND VPWR VPWR _6873_/D sky130_fd_sc_hd__dlygate4sd3_1
Xhold759 _6868_/Q VGND VGND VPWR VPWR _6868_/D sky130_fd_sc_hd__dlygate4sd3_1
X_3454_ _7186_/Q _3994_/S _4532_/S _7031_/Q _3453_/X VGND VGND VPWR VPWR _3454_/X
+ sky130_fd_sc_hd__a221o_2
XTAP_TAPCELL_ROW_73_1129 VGND VPWR sky130_fd_sc_hd__tapvpwrvgnd_1
XFILLER_103_329 VGND VGND VPWR VPWR sky130_fd_sc_hd__decap_3
XFILLER_115_178 VGND VGND VPWR VPWR sky130_fd_sc_hd__fill_1
XFILLER_69_210 VGND VGND VPWR VPWR sky130_fd_sc_hd__decap_3
XFILLER_69_243 VGND VGND VPWR VPWR sky130_fd_sc_hd__decap_3
XFILLER_97_541 VGND VGND VPWR VPWR sky130_fd_sc_hd__decap_3
X_3385_ _3561_/B _5130_/A VGND VGND VPWR VPWR _3385_/Y sky130_fd_sc_hd__nor2_2
XFILLER_57_405 VGND VGND VPWR VPWR sky130_fd_sc_hd__decap_3
XFILLER_69_287 VGND VGND VPWR VPWR sky130_fd_sc_hd__decap_3
X_5124_ _3746_/B _3900_/Y _4677_/B VGND VGND VPWR VPWR _5125_/B sky130_fd_sc_hd__a21o_2
XFILLER_57_449 VGND VGND VPWR VPWR sky130_fd_sc_hd__decap_3
XFILLER_84_213 VGND VGND VPWR VPWR sky130_fd_sc_hd__decap_3
XFILLER_84_246 VGND VGND VPWR VPWR sky130_fd_sc_hd__fill_1
X_5055_ _5103_/A1 _5049_/X _5053_/Y _5054_/Y _4369_/A VGND VGND VPWR VPWR _5055_/X
+ sky130_fd_sc_hd__a221o_2
XFILLER_37_140 VGND VGND VPWR VPWR sky130_fd_sc_hd__decap_3
XFILLER_55_19 VGND VGND VPWR VPWR sky130_fd_sc_hd__decap_3
XFILLER_72_419 VGND VGND VPWR VPWR sky130_fd_sc_hd__fill_1
XFILLER_84_279 VGND VGND VPWR VPWR sky130_fd_sc_hd__decap_3
XFILLER_1_90 VGND VGND VPWR VPWR sky130_fd_sc_hd__fill_1
XFILLER_25_302 VGND VGND VPWR VPWR sky130_fd_sc_hd__decap_3
XFILLER_37_184 VGND VGND VPWR VPWR sky130_fd_sc_hd__decap_3
XFILLER_111_25 VGND VGND VPWR VPWR sky130_fd_sc_hd__decap_3
XFILLER_25_335 VGND VGND VPWR VPWR sky130_fd_sc_hd__fill_1
XFILLER_25_346 VGND VGND VPWR VPWR sky130_fd_sc_hd__decap_3
XFILLER_52_121 VGND VGND VPWR VPWR sky130_fd_sc_hd__fill_2
XFILLER_80_430 VGND VGND VPWR VPWR sky130_fd_sc_hd__decap_3
XTAP_TAPCELL_ROW_84_1258 VGND VPWR sky130_fd_sc_hd__tapvpwrvgnd_1
XFILLER_25_379 VGND VGND VPWR VPWR sky130_fd_sc_hd__decap_3
XFILLER_52_165 VGND VGND VPWR VPWR sky130_fd_sc_hd__decap_3
XFILLER_40_327 VGND VGND VPWR VPWR sky130_fd_sc_hd__decap_3
X_4908_ _4908_/A _4908_/B VGND VGND VPWR VPWR _4909_/C sky130_fd_sc_hd__nor2_2
XTAP_TAPCELL_ROW_23_525 VGND VPWR sky130_fd_sc_hd__tapvpwrvgnd_1
XTAP_TAPCELL_ROW_51_867 VGND VPWR sky130_fd_sc_hd__tapvpwrvgnd_1
X_4839_ _4916_/A _4916_/B _4634_/Y VGND VGND VPWR VPWR _4903_/C sky130_fd_sc_hd__a21o_2
XFILLER_4_206 VGND VGND VPWR VPWR sky130_fd_sc_hd__decap_3
X_6509_ _6606_/A VGND VGND VPWR VPWR _6509_/Y sky130_fd_sc_hd__inv_2
XFILLER_20_44 VGND VGND VPWR VPWR sky130_fd_sc_hd__decap_3
XTAP_TAPCELL_ROW_95_1387 VGND VPWR sky130_fd_sc_hd__tapvpwrvgnd_1
XFILLER_106_189 VGND VGND VPWR VPWR sky130_fd_sc_hd__decap_3
XFILLER_96_26 VGND VGND VPWR VPWR sky130_fd_sc_hd__fill_2
XFILLER_29_20 VGND VGND VPWR VPWR sky130_fd_sc_hd__decap_3
XFILLER_96_59 VGND VGND VPWR VPWR sky130_fd_sc_hd__decap_3
XFILLER_102_351 VGND VGND VPWR VPWR sky130_fd_sc_hd__decap_3
XFILLER_29_53 VGND VGND VPWR VPWR sky130_fd_sc_hd__decap_3
XFILLER_48_416 VGND VGND VPWR VPWR sky130_fd_sc_hd__decap_3
XFILLER_48_427 VGND VGND VPWR VPWR sky130_fd_sc_hd__decap_3
XFILLER_75_202 VGND VGND VPWR VPWR sky130_fd_sc_hd__decap_3
XFILLER_102_384 VGND VGND VPWR VPWR sky130_fd_sc_hd__decap_3
XFILLER_29_75 VGND VGND VPWR VPWR sky130_fd_sc_hd__decap_3
XFILLER_75_213 VGND VGND VPWR VPWR sky130_fd_sc_hd__decap_3
XFILLER_75_246 VGND VGND VPWR VPWR sky130_fd_sc_hd__decap_3
XTAP_TAPCELL_ROW_59_956 VGND VPWR sky130_fd_sc_hd__tapvpwrvgnd_1
XFILLER_63_408 VGND VGND VPWR VPWR sky130_fd_sc_hd__decap_3
XFILLER_28_162 VGND VGND VPWR VPWR sky130_fd_sc_hd__decap_3
XFILLER_44_622 VGND VGND VPWR VPWR sky130_fd_sc_hd__decap_3
XFILLER_90_216 VGND VGND VPWR VPWR sky130_fd_sc_hd__decap_3
Xplace408 _4505_/S VGND VGND VPWR VPWR _4534_/S sky130_fd_sc_hd__buf_2
Xplace419 _3380_/Y VGND VGND VPWR VPWR _4332_/B1 sky130_fd_sc_hd__buf_2
XTAP_TAPCELL_ROW_3_283 VGND VPWR sky130_fd_sc_hd__tapvpwrvgnd_1
XFILLER_28_195 VGND VGND VPWR VPWR sky130_fd_sc_hd__fill_1
XFILLER_45_41 VGND VGND VPWR VPWR sky130_fd_sc_hd__fill_2
XFILLER_71_441 VGND VGND VPWR VPWR sky130_fd_sc_hd__decap_3
XFILLER_90_249 VGND VGND VPWR VPWR sky130_fd_sc_hd__decap_3
XFILLER_16_368 VGND VGND VPWR VPWR sky130_fd_sc_hd__decap_3
XFILLER_43_154 VGND VGND VPWR VPWR sky130_fd_sc_hd__decap_3
XFILLER_44_688 VGND VGND VPWR VPWR sky130_fd_sc_hd__fill_1
XFILLER_45_85 VGND VGND VPWR VPWR sky130_fd_sc_hd__decap_3
XFILLER_31_349 VGND VGND VPWR VPWR sky130_fd_sc_hd__fill_2
XFILLER_43_187 VGND VGND VPWR VPWR sky130_fd_sc_hd__decap_3
XTAP_TAPCELL_ROW_104_1494 VGND VPWR sky130_fd_sc_hd__tapvpwrvgnd_1
XFILLER_77_9 VGND VGND VPWR VPWR sky130_fd_sc_hd__decap_3
XANTENNA_6 _5633_/B VGND VGND VPWR VPWR sky130_fd_sc_hd__diode_2
XFILLER_6_35 VGND VGND VPWR VPWR sky130_fd_sc_hd__decap_3
XFILLER_98_305 VGND VGND VPWR VPWR sky130_fd_sc_hd__decap_3
XFILLER_3_261 VGND VGND VPWR VPWR sky130_fd_sc_hd__decap_3
XFILLER_39_405 VGND VGND VPWR VPWR sky130_fd_sc_hd__decap_3
XFILLER_79_574 VGND VGND VPWR VPWR sky130_fd_sc_hd__decap_3
XFILLER_39_449 VGND VGND VPWR VPWR sky130_fd_sc_hd__fill_1
XFILLER_66_224 VGND VGND VPWR VPWR sky130_fd_sc_hd__decap_3
XFILLER_79_596 VGND VGND VPWR VPWR sky130_fd_sc_hd__decap_3
XFILLER_94_533 VGND VGND VPWR VPWR sky130_fd_sc_hd__decap_3
XFILLER_94_577 VGND VGND VPWR VPWR sky130_fd_sc_hd__decap_3
XFILLER_81_205 VGND VGND VPWR VPWR sky130_fd_sc_hd__decap_3
XFILLER_34_132 VGND VGND VPWR VPWR sky130_fd_sc_hd__decap_3
XFILLER_35_644 VGND VGND VPWR VPWR sky130_fd_sc_hd__decap_3
XFILLER_62_430 VGND VGND VPWR VPWR sky130_fd_sc_hd__decap_3
X_6860_ _6968_/CLK _6860_/D VGND VGND VPWR VPWR _6860_/Q sky130_fd_sc_hd__dfxtp_2
XFILLER_22_305 VGND VGND VPWR VPWR sky130_fd_sc_hd__decap_3
XFILLER_34_176 VGND VGND VPWR VPWR sky130_fd_sc_hd__decap_3
XFILLER_62_463 VGND VGND VPWR VPWR sky130_fd_sc_hd__decap_3
X_6791_ _7390_/CLK _6791_/D VGND VGND VPWR VPWR _6791_/Q sky130_fd_sc_hd__dfxtp_2
XFILLER_30_371 VGND VGND VPWR VPWR sky130_fd_sc_hd__fill_2
X_7412_ _7412_/A VGND VGND VPWR VPWR _7412_/X sky130_fd_sc_hd__buf_2
X_4624_ _4624_/A _4624_/B VGND VGND VPWR VPWR _4624_/X sky130_fd_sc_hd__and2_2
XPHY_EDGE_ROW_6_Right_6 VGND VGND VPWR VPWR sky130_fd_sc_hd__decap_3
XFILLER_116_421 VGND VGND VPWR VPWR sky130_fd_sc_hd__decap_3
X_7343_ _7394_/CLK _7343_/D _6623_/Y VGND VGND VPWR VPWR _7343_/Q sky130_fd_sc_hd__dfrtp_2
X_3506_ _3544_/A _3506_/B VGND VGND VPWR VPWR _3506_/Y sky130_fd_sc_hd__nand2_2
X_7274_ _7307_/CLK _7274_/D _6554_/Y VGND VGND VPWR VPWR _7274_/Q sky130_fd_sc_hd__dfrtp_2
X_4486_ _7336_/Q _7304_/Q _4486_/S VGND VGND VPWR VPWR _7336_/D sky130_fd_sc_hd__mux2_2
XFILLER_106_36 VGND VGND VPWR VPWR sky130_fd_sc_hd__decap_3
Xhold589 _6904_/Q VGND VGND VPWR VPWR _6904_/D sky130_fd_sc_hd__dlygate4sd3_1
XFILLER_103_159 VGND VGND VPWR VPWR sky130_fd_sc_hd__fill_1
XFILLER_106_58 VGND VGND VPWR VPWR sky130_fd_sc_hd__decap_3
XFILLER_97_360 VGND VGND VPWR VPWR sky130_fd_sc_hd__decap_3
X_3368_ _3386_/A _5294_/A _3310_/Y _6983_/Q VGND VGND VPWR VPWR _3368_/Y sky130_fd_sc_hd__a211oi_4
XFILLER_66_29 VGND VGND VPWR VPWR sky130_fd_sc_hd__decap_3
XFILLER_97_382 VGND VGND VPWR VPWR sky130_fd_sc_hd__decap_3
XFILLER_97_393 VGND VGND VPWR VPWR sky130_fd_sc_hd__decap_3
Xhold1201 _7283_/Q VGND VGND VPWR VPWR _4595_/A sky130_fd_sc_hd__dlygate4sd3_1
X_5107_ _5156_/S _6985_/D _5105_/X _5106_/X VGND VGND VPWR VPWR _5107_/X sky130_fd_sc_hd__o22a_2
XFILLER_45_408 VGND VGND VPWR VPWR sky130_fd_sc_hd__decap_3
XFILLER_57_246 VGND VGND VPWR VPWR sky130_fd_sc_hd__decap_3
X_3299_ _3353_/A _6979_/Q _3327_/A VGND VGND VPWR VPWR _3328_/A sky130_fd_sc_hd__o21a_2
X_5038_ _5038_/A _5038_/B VGND VGND VPWR VPWR _5038_/X sky130_fd_sc_hd__xor2_2
XTAP_TAPCELL_ROW_56_926 VGND VPWR sky130_fd_sc_hd__tapvpwrvgnd_1
XFILLER_53_441 VGND VGND VPWR VPWR sky130_fd_sc_hd__decap_3
XFILLER_72_249 VGND VGND VPWR VPWR sky130_fd_sc_hd__decap_3
XTAP_TAPCELL_ROW_0_253 VGND VPWR sky130_fd_sc_hd__tapvpwrvgnd_1
XTAP_TAPCELL_ROW_0_242 VGND VPWR sky130_fd_sc_hd__tapvpwrvgnd_1
XFILLER_41_614 VGND VGND VPWR VPWR sky130_fd_sc_hd__fill_2
XFILLER_41_625 VGND VGND VPWR VPWR sky130_fd_sc_hd__fill_2
XFILLER_15_33 VGND VGND VPWR VPWR sky130_fd_sc_hd__decap_3
XFILLER_25_187 VGND VGND VPWR VPWR sky130_fd_sc_hd__decap_3
XFILLER_40_124 VGND VGND VPWR VPWR sky130_fd_sc_hd__decap_3
XFILLER_53_496 VGND VGND VPWR VPWR sky130_fd_sc_hd__decap_3
XFILLER_80_271 VGND VGND VPWR VPWR sky130_fd_sc_hd__decap_3
X_6989_ _7393_/CLK _6989_/D _6269_/Y VGND VGND VPWR VPWR _6989_/Q sky130_fd_sc_hd__dfrtp_2
XTAP_TAPCELL_ROW_36_683 VGND VPWR sky130_fd_sc_hd__tapvpwrvgnd_1
XFILLER_15_77 VGND VGND VPWR VPWR sky130_fd_sc_hd__decap_3
XFILLER_40_168 VGND VGND VPWR VPWR sky130_fd_sc_hd__decap_3
XFILLER_41_669 VGND VGND VPWR VPWR sky130_fd_sc_hd__decap_3
XFILLER_21_393 VGND VGND VPWR VPWR sky130_fd_sc_hd__decap_3
XTAP_TAPCELL_ROW_97_1416 VGND VPWR sky130_fd_sc_hd__tapvpwrvgnd_1
XFILLER_107_410 VGND VGND VPWR VPWR sky130_fd_sc_hd__decap_3
XFILLER_110_3 VGND VGND VPWR VPWR sky130_fd_sc_hd__decap_3
XFILLER_31_65 VGND VGND VPWR VPWR sky130_fd_sc_hd__decap_3
XFILLER_107_432 VGND VGND VPWR VPWR sky130_fd_sc_hd__fill_2
XFILLER_107_476 VGND VGND VPWR VPWR sky130_fd_sc_hd__decap_3
XTAP_TAPCELL_ROW_8_353 VGND VPWR sky130_fd_sc_hd__tapvpwrvgnd_1
XTAP_TAPCELL_ROW_8_342 VGND VPWR sky130_fd_sc_hd__tapvpwrvgnd_1
XFILLER_0_231 VGND VGND VPWR VPWR sky130_fd_sc_hd__decap_3
XFILLER_0_242 VGND VGND VPWR VPWR sky130_fd_sc_hd__fill_2
XFILLER_0_253 VGND VGND VPWR VPWR sky130_fd_sc_hd__decap_3
XFILLER_103_671 VGND VGND VPWR VPWR sky130_fd_sc_hd__fill_1
XFILLER_110_608 VGND VGND VPWR VPWR sky130_fd_sc_hd__decap_3
XFILLER_0_275 VGND VGND VPWR VPWR sky130_fd_sc_hd__decap_3
XFILLER_48_235 VGND VGND VPWR VPWR sky130_fd_sc_hd__decap_3
XFILLER_76_522 VGND VGND VPWR VPWR sky130_fd_sc_hd__decap_3
XFILLER_76_533 VGND VGND VPWR VPWR sky130_fd_sc_hd__decap_3
XFILLER_88_371 VGND VGND VPWR VPWR sky130_fd_sc_hd__decap_3
XFILLER_48_268 VGND VGND VPWR VPWR sky130_fd_sc_hd__fill_2
XFILLER_76_555 VGND VGND VPWR VPWR sky130_fd_sc_hd__decap_3
XFILLER_56_62 VGND VGND VPWR VPWR sky130_fd_sc_hd__decap_3
XFILLER_91_514 VGND VGND VPWR VPWR sky130_fd_sc_hd__decap_3
XFILLER_44_430 VGND VGND VPWR VPWR sky130_fd_sc_hd__decap_3
XFILLER_63_249 VGND VGND VPWR VPWR sky130_fd_sc_hd__decap_3
XTAP_TAPCELL_ROW_106_1523 VGND VPWR sky130_fd_sc_hd__tapvpwrvgnd_1
XFILLER_16_165 VGND VGND VPWR VPWR sky130_fd_sc_hd__decap_3
XFILLER_44_474 VGND VGND VPWR VPWR sky130_fd_sc_hd__fill_2
XFILLER_31_113 VGND VGND VPWR VPWR sky130_fd_sc_hd__decap_3
XFILLER_71_293 VGND VGND VPWR VPWR sky130_fd_sc_hd__decap_3
XFILLER_72_50 VGND VGND VPWR VPWR sky130_fd_sc_hd__decap_3
XFILLER_31_146 VGND VGND VPWR VPWR sky130_fd_sc_hd__decap_3
XFILLER_12_371 VGND VGND VPWR VPWR sky130_fd_sc_hd__decap_3
XFILLER_31_179 VGND VGND VPWR VPWR sky130_fd_sc_hd__decap_3
XPHY_EDGE_ROW_59_Right_59 VGND VGND VPWR VPWR sky130_fd_sc_hd__decap_3
XFILLER_75_6 VGND VGND VPWR VPWR sky130_fd_sc_hd__decap_3
XFILLER_113_402 VGND VGND VPWR VPWR sky130_fd_sc_hd__decap_3
X_4340_ _7223_/Q _4340_/A2 _4338_/X _4339_/X VGND VGND VPWR VPWR _4340_/X sky130_fd_sc_hd__a211o_2
XFILLER_113_435 VGND VGND VPWR VPWR sky130_fd_sc_hd__decap_3
X_4271_ _4271_/A _4271_/B _4271_/C _4270_/Y VGND VGND VPWR VPWR _4271_/X sky130_fd_sc_hd__or4b_2
XFILLER_98_124 VGND VGND VPWR VPWR sky130_fd_sc_hd__decap_3
XFILLER_98_179 VGND VGND VPWR VPWR sky130_fd_sc_hd__fill_1
XFILLER_97_80 VGND VGND VPWR VPWR sky130_fd_sc_hd__decap_3
XFILLER_67_511 VGND VGND VPWR VPWR sky130_fd_sc_hd__decap_3
XFILLER_79_393 VGND VGND VPWR VPWR sky130_fd_sc_hd__decap_3
XPHY_EDGE_ROW_68_Right_68 VGND VGND VPWR VPWR sky130_fd_sc_hd__decap_3
XFILLER_67_544 VGND VGND VPWR VPWR sky130_fd_sc_hd__decap_3
XFILLER_94_330 VGND VGND VPWR VPWR sky130_fd_sc_hd__decap_3
XFILLER_54_227 VGND VGND VPWR VPWR sky130_fd_sc_hd__decap_3
XFILLER_67_588 VGND VGND VPWR VPWR sky130_fd_sc_hd__decap_3
XFILLER_35_441 VGND VGND VPWR VPWR sky130_fd_sc_hd__decap_3
X_6912_ _7390_/CLK _6912_/D VGND VGND VPWR VPWR _6912_/Q sky130_fd_sc_hd__dfxtp_2
X_6843_ _6978_/CLK _6843_/D VGND VGND VPWR VPWR _6843_/Q sky130_fd_sc_hd__dfxtp_2
XFILLER_62_293 VGND VGND VPWR VPWR sky130_fd_sc_hd__fill_1
XTAP_TAPCELL_ROW_81_1228 VGND VPWR sky130_fd_sc_hd__tapvpwrvgnd_1
XFILLER_22_135 VGND VGND VPWR VPWR sky130_fd_sc_hd__decap_3
XFILLER_50_444 VGND VGND VPWR VPWR sky130_fd_sc_hd__decap_3
XFILLER_50_466 VGND VGND VPWR VPWR sky130_fd_sc_hd__decap_3
X_6774_ _6909_/CLK _6774_/D VGND VGND VPWR VPWR _6774_/Q sky130_fd_sc_hd__dfxtp_2
XTAP_TAPCELL_ROW_33_653 VGND VPWR sky130_fd_sc_hd__tapvpwrvgnd_1
XTAP_TAPCELL_ROW_33_642 VGND VPWR sky130_fd_sc_hd__tapvpwrvgnd_1
XPHY_EDGE_ROW_77_Right_77 VGND VGND VPWR VPWR sky130_fd_sc_hd__decap_3
XFILLER_50_499 VGND VGND VPWR VPWR sky130_fd_sc_hd__decap_3
X_5725_ _7368_/Q hold930/X _5737_/S VGND VGND VPWR VPWR _6712_/D sky130_fd_sc_hd__mux2_2
XTAP_TAPCELL_ROW_61_984 VGND VPWR sky130_fd_sc_hd__tapvpwrvgnd_1
X_5656_ _5656_/A _5656_/B _5656_/C VGND VGND VPWR VPWR _5665_/C sky130_fd_sc_hd__nor3_2
XFILLER_108_229 VGND VGND VPWR VPWR sky130_fd_sc_hd__decap_3
XFILLER_116_240 VGND VGND VPWR VPWR sky130_fd_sc_hd__decap_3
X_5587_ _5587_/A _5587_/B VGND VGND VPWR VPWR _7034_/D sky130_fd_sc_hd__and2_2
XFILLER_116_262 VGND VGND VPWR VPWR sky130_fd_sc_hd__decap_3
XFILLER_89_102 VGND VGND VPWR VPWR sky130_fd_sc_hd__decap_3
XFILLER_89_113 VGND VGND VPWR VPWR sky130_fd_sc_hd__decap_3
X_7326_ _7359_/CLK _7326_/D _6606_/Y VGND VGND VPWR VPWR _7326_/Q sky130_fd_sc_hd__dfrtp_2
XFILLER_116_295 VGND VGND VPWR VPWR sky130_fd_sc_hd__decap_3
XFILLER_7_9 VGND VGND VPWR VPWR sky130_fd_sc_hd__decap_3
X_7257_ clkload6/A _7257_/D _6537_/Y VGND VGND VPWR VPWR _7257_/Q sky130_fd_sc_hd__dfrtp_2
X_4469_ _7009_/Q _4467_/A _4469_/A3 _4468_/X VGND VGND VPWR VPWR _4469_/X sky130_fd_sc_hd__a31o_2
XTAP_TAPCELL_ROW_92_1357 VGND VPWR sky130_fd_sc_hd__tapvpwrvgnd_1
XFILLER_77_319 VGND VGND VPWR VPWR sky130_fd_sc_hd__decap_3
XFILLER_89_157 VGND VGND VPWR VPWR sky130_fd_sc_hd__decap_3
XTAP_TAPCELL_ROW_5_312 VGND VPWR sky130_fd_sc_hd__tapvpwrvgnd_1
XPHY_EDGE_ROW_86_Right_86 VGND VGND VPWR VPWR sky130_fd_sc_hd__decap_3
XFILLER_58_533 VGND VGND VPWR VPWR sky130_fd_sc_hd__decap_3
X_7188_ clkload4/A _7188_/D _6468_/Y VGND VGND VPWR VPWR _7188_/Q sky130_fd_sc_hd__dfrtp_2
Xhold1020 _7207_/Q VGND VGND VPWR VPWR _5245_/A0 sky130_fd_sc_hd__dlygate4sd3_1
Xhold1031 _7219_/Q VGND VGND VPWR VPWR _5219_/A sky130_fd_sc_hd__dlygate4sd3_1
Xhold1042 _7214_/Q VGND VGND VPWR VPWR _5232_/A0 sky130_fd_sc_hd__dlygate4sd3_1
XFILLER_45_216 VGND VGND VPWR VPWR sky130_fd_sc_hd__decap_3
XFILLER_73_514 VGND VGND VPWR VPWR sky130_fd_sc_hd__decap_3
XFILLER_85_396 VGND VGND VPWR VPWR sky130_fd_sc_hd__decap_3
Xhold1053 _7255_/Q VGND VGND VPWR VPWR _5108_/A0 sky130_fd_sc_hd__dlygate4sd3_1
Xhold1064 _7381_/Q VGND VGND VPWR VPWR _3901_/A1 sky130_fd_sc_hd__dlygate4sd3_1
Xhold1075 _7399_/Q VGND VGND VPWR VPWR _3710_/A1 sky130_fd_sc_hd__dlygate4sd3_1
XFILLER_26_21 VGND VGND VPWR VPWR sky130_fd_sc_hd__decap_3
XFILLER_26_32 VGND VGND VPWR VPWR sky130_fd_sc_hd__decap_3
XFILLER_73_569 VGND VGND VPWR VPWR sky130_fd_sc_hd__decap_3
Xhold1086 _7314_/Q VGND VGND VPWR VPWR _4530_/A0 sky130_fd_sc_hd__dlygate4sd3_1
Xhold1097 _7316_/Q VGND VGND VPWR VPWR _4526_/A0 sky130_fd_sc_hd__dlygate4sd3_1
XFILLER_60_208 VGND VGND VPWR VPWR sky130_fd_sc_hd__decap_3
XFILLER_13_113 VGND VGND VPWR VPWR sky130_fd_sc_hd__decap_3
XFILLER_26_76 VGND VGND VPWR VPWR sky130_fd_sc_hd__decap_3
XFILLER_41_422 VGND VGND VPWR VPWR sky130_fd_sc_hd__decap_3
XFILLER_53_293 VGND VGND VPWR VPWR sky130_fd_sc_hd__decap_3
XFILLER_81_580 VGND VGND VPWR VPWR sky130_fd_sc_hd__fill_1
XFILLER_81_591 VGND VGND VPWR VPWR sky130_fd_sc_hd__decap_3
XPHY_EDGE_ROW_95_Right_95 VGND VGND VPWR VPWR sky130_fd_sc_hd__decap_3
XFILLER_41_444 VGND VGND VPWR VPWR sky130_fd_sc_hd__decap_3
XFILLER_41_466 VGND VGND VPWR VPWR sky130_fd_sc_hd__decap_3
XTAP_TAPCELL_ROW_101_1464 VGND VPWR sky130_fd_sc_hd__tapvpwrvgnd_1
XFILLER_9_128 VGND VGND VPWR VPWR sky130_fd_sc_hd__decap_3
XFILLER_21_190 VGND VGND VPWR VPWR sky130_fd_sc_hd__decap_3
XFILLER_42_97 VGND VGND VPWR VPWR sky130_fd_sc_hd__decap_3
XFILLER_5_323 VGND VGND VPWR VPWR sky130_fd_sc_hd__decap_3
XFILLER_107_240 VGND VGND VPWR VPWR sky130_fd_sc_hd__decap_3
XFILLER_5_367 VGND VGND VPWR VPWR sky130_fd_sc_hd__decap_3
XPHY_EDGE_ROW_39_Left_156 VGND VGND VPWR VPWR sky130_fd_sc_hd__decap_3
XFILLER_110_416 VGND VGND VPWR VPWR sky130_fd_sc_hd__decap_3
XFILLER_110_427 VGND VGND VPWR VPWR sky130_fd_sc_hd__decap_3
XFILLER_89_691 VGND VGND VPWR VPWR sky130_fd_sc_hd__fill_1
XFILLER_95_127 VGND VGND VPWR VPWR sky130_fd_sc_hd__decap_3
XTAP_TAPCELL_ROW_112_1593 VGND VPWR sky130_fd_sc_hd__tapvpwrvgnd_1
XFILLER_49_544 VGND VGND VPWR VPWR sky130_fd_sc_hd__decap_3
XFILLER_76_330 VGND VGND VPWR VPWR sky130_fd_sc_hd__decap_3
XFILLER_36_216 VGND VGND VPWR VPWR sky130_fd_sc_hd__fill_2
XFILLER_64_525 VGND VGND VPWR VPWR sky130_fd_sc_hd__decap_3
XFILLER_76_374 VGND VGND VPWR VPWR sky130_fd_sc_hd__decap_3
XFILLER_91_300 VGND VGND VPWR VPWR sky130_fd_sc_hd__decap_3
XFILLER_36_227 VGND VGND VPWR VPWR sky130_fd_sc_hd__decap_3
XFILLER_64_536 VGND VGND VPWR VPWR sky130_fd_sc_hd__decap_3
XPHY_EDGE_ROW_48_Left_165 VGND VGND VPWR VPWR sky130_fd_sc_hd__decap_3
XFILLER_17_452 VGND VGND VPWR VPWR sky130_fd_sc_hd__decap_3
XFILLER_83_60 VGND VGND VPWR VPWR sky130_fd_sc_hd__decap_3
XFILLER_83_71 VGND VGND VPWR VPWR sky130_fd_sc_hd__decap_3
XFILLER_91_355 VGND VGND VPWR VPWR sky130_fd_sc_hd__decap_3
XTAP_TAPCELL_ROW_67_1061 VGND VPWR sky130_fd_sc_hd__tapvpwrvgnd_1
XTAP_TAPCELL_ROW_67_1050 VGND VPWR sky130_fd_sc_hd__tapvpwrvgnd_1
XFILLER_44_271 VGND VGND VPWR VPWR sky130_fd_sc_hd__fill_1
XFILLER_91_399 VGND VGND VPWR VPWR sky130_fd_sc_hd__decap_3
XFILLER_32_466 VGND VGND VPWR VPWR sky130_fd_sc_hd__decap_3
X_3840_ _6835_/Q _3853_/A2 _3852_/B1 _6840_/Q VGND VGND VPWR VPWR _3840_/X sky130_fd_sc_hd__a22o_2
X_3771_ _6910_/Q _3869_/A2 _3882_/A2 _6862_/Q VGND VGND VPWR VPWR _3771_/X sky130_fd_sc_hd__a22o_2
XTAP_TAPCELL_ROW_30_612 VGND VPWR sky130_fd_sc_hd__tapvpwrvgnd_1
XFILLER_8_150 VGND VGND VPWR VPWR sky130_fd_sc_hd__decap_3
X_6490_ _6548_/A VGND VGND VPWR VPWR _6490_/Y sky130_fd_sc_hd__inv_2
XFILLER_8_183 VGND VGND VPWR VPWR sky130_fd_sc_hd__decap_3
XPHY_EDGE_ROW_57_Left_174 VGND VGND VPWR VPWR sky130_fd_sc_hd__decap_3
XTAP_TAPCELL_ROW_78_1190 VGND VPWR sky130_fd_sc_hd__tapvpwrvgnd_1
XFILLER_113_210 VGND VGND VPWR VPWR sky130_fd_sc_hd__decap_3
X_7111_ _7338_/CLK _7111_/D _6391_/Y VGND VGND VPWR VPWR _7111_/Q sky130_fd_sc_hd__dfrtp_2
Xoutput469 _5023_/Y VGND VGND VPWR VPWR alu_result_out[13] sky130_fd_sc_hd__clkdlybuf4s25_1
X_4323_ _7226_/Q _4469_/A3 _3968_/S _7194_/Q VGND VGND VPWR VPWR _4323_/X sky130_fd_sc_hd__a22o_2
XFILLER_99_444 VGND VGND VPWR VPWR sky130_fd_sc_hd__decap_3
XFILLER_101_405 VGND VGND VPWR VPWR sky130_fd_sc_hd__fill_1
XFILLER_113_265 VGND VGND VPWR VPWR sky130_fd_sc_hd__decap_3
XFILLER_59_308 VGND VGND VPWR VPWR sky130_fd_sc_hd__decap_3
XFILLER_87_617 VGND VGND VPWR VPWR sky130_fd_sc_hd__decap_3
X_7042_ _7401_/CLK _7042_/D _6322_/Y VGND VGND VPWR VPWR _7042_/Q sky130_fd_sc_hd__dfrtp_2
XFILLER_99_488 VGND VGND VPWR VPWR sky130_fd_sc_hd__decap_3
XFILLER_99_455 VGND VGND VPWR VPWR sky130_fd_sc_hd__decap_3
XFILLER_101_427 VGND VGND VPWR VPWR sky130_fd_sc_hd__decap_3
XFILLER_113_287 VGND VGND VPWR VPWR sky130_fd_sc_hd__decap_3
XFILLER_86_127 VGND VGND VPWR VPWR sky130_fd_sc_hd__decap_3
X_4254_ _7229_/Q _4469_/A3 _4507_/S _7042_/Q _4253_/X VGND VGND VPWR VPWR _4254_/X
+ sky130_fd_sc_hd__a221o_2
XFILLER_101_449 VGND VGND VPWR VPWR sky130_fd_sc_hd__decap_3
XFILLER_67_352 VGND VGND VPWR VPWR sky130_fd_sc_hd__decap_3
X_4185_ _4537_/C _4289_/B _4185_/C VGND VGND VPWR VPWR _4636_/B sky130_fd_sc_hd__and3_2
XTAP_TAPCELL_ROW_38_712 VGND VPWR sky130_fd_sc_hd__tapvpwrvgnd_1
XPHY_EDGE_ROW_66_Left_183 VGND VGND VPWR VPWR sky130_fd_sc_hd__decap_3
XFILLER_103_37 VGND VGND VPWR VPWR sky130_fd_sc_hd__decap_3
XFILLER_55_558 VGND VGND VPWR VPWR sky130_fd_sc_hd__fill_2
XFILLER_55_569 VGND VGND VPWR VPWR sky130_fd_sc_hd__decap_3
XFILLER_63_19 VGND VGND VPWR VPWR sky130_fd_sc_hd__decap_3
XFILLER_70_517 VGND VGND VPWR VPWR sky130_fd_sc_hd__decap_3
XFILLER_82_355 VGND VGND VPWR VPWR sky130_fd_sc_hd__decap_3
XFILLER_23_411 VGND VGND VPWR VPWR sky130_fd_sc_hd__decap_3
XFILLER_35_260 VGND VGND VPWR VPWR sky130_fd_sc_hd__decap_3
XFILLER_70_539 VGND VGND VPWR VPWR sky130_fd_sc_hd__decap_3
XFILLER_23_455 VGND VGND VPWR VPWR sky130_fd_sc_hd__decap_3
XFILLER_50_241 VGND VGND VPWR VPWR sky130_fd_sc_hd__decap_3
X_6826_ _6976_/CLK _6826_/D VGND VGND VPWR VPWR _6826_/Q sky130_fd_sc_hd__dfxtp_2
XFILLER_50_285 VGND VGND VPWR VPWR sky130_fd_sc_hd__decap_3
X_6757_ _6968_/CLK _6757_/D VGND VGND VPWR VPWR _6757_/Q sky130_fd_sc_hd__dfxtp_2
XFILLER_10_127 VGND VGND VPWR VPWR sky130_fd_sc_hd__decap_3
XFILLER_12_12 VGND VGND VPWR VPWR sky130_fd_sc_hd__decap_3
X_5708_ _7360_/Q hold931/X _5708_/S VGND VGND VPWR VPWR _6704_/D sky130_fd_sc_hd__mux2_2
X_6688_ _7383_/CLK _6688_/D VGND VGND VPWR VPWR _6688_/Q sky130_fd_sc_hd__dfxtp_2
XPHY_EDGE_ROW_75_Left_192 VGND VGND VPWR VPWR sky130_fd_sc_hd__decap_3
XFILLER_12_56 VGND VGND VPWR VPWR sky130_fd_sc_hd__decap_3
XFILLER_12_78 VGND VGND VPWR VPWR sky130_fd_sc_hd__decap_3
XFILLER_104_210 VGND VGND VPWR VPWR sky130_fd_sc_hd__fill_1
XFILLER_5_6 VGND VGND VPWR VPWR sky130_fd_sc_hd__decap_3
X_7309_ _7403_/CLK _7309_/D _6589_/Y VGND VGND VPWR VPWR _7309_/Q sky130_fd_sc_hd__dfrtp_2
XFILLER_104_243 VGND VGND VPWR VPWR sky130_fd_sc_hd__decap_3
XFILLER_78_628 VGND VGND VPWR VPWR sky130_fd_sc_hd__decap_3
XFILLER_104_287 VGND VGND VPWR VPWR sky130_fd_sc_hd__decap_3
XFILLER_77_138 VGND VGND VPWR VPWR sky130_fd_sc_hd__decap_3
XFILLER_58_341 VGND VGND VPWR VPWR sky130_fd_sc_hd__decap_3
XFILLER_100_460 VGND VGND VPWR VPWR sky130_fd_sc_hd__fill_1
XFILLER_100_471 VGND VGND VPWR VPWR sky130_fd_sc_hd__decap_3
XFILLER_46_525 VGND VGND VPWR VPWR sky130_fd_sc_hd__decap_3
XFILLER_85_160 VGND VGND VPWR VPWR sky130_fd_sc_hd__decap_3
XFILLER_86_661 VGND VGND VPWR VPWR sky130_fd_sc_hd__fill_2
XFILLER_18_227 VGND VGND VPWR VPWR sky130_fd_sc_hd__decap_3
XFILLER_18_238 VGND VGND VPWR VPWR sky130_fd_sc_hd__decap_3
XFILLER_46_536 VGND VGND VPWR VPWR sky130_fd_sc_hd__fill_1
XFILLER_73_322 VGND VGND VPWR VPWR sky130_fd_sc_hd__decap_3
XFILLER_85_182 VGND VGND VPWR VPWR sky130_fd_sc_hd__decap_3
XFILLER_33_208 VGND VGND VPWR VPWR sky130_fd_sc_hd__decap_3
XFILLER_37_97 VGND VGND VPWR VPWR sky130_fd_sc_hd__decap_3
XFILLER_73_355 VGND VGND VPWR VPWR sky130_fd_sc_hd__decap_3
XFILLER_73_377 VGND VGND VPWR VPWR sky130_fd_sc_hd__decap_3
XFILLER_14_411 VGND VGND VPWR VPWR sky130_fd_sc_hd__decap_3
XFILLER_26_260 VGND VGND VPWR VPWR sky130_fd_sc_hd__decap_3
XFILLER_33_219 VGND VGND VPWR VPWR sky130_fd_sc_hd__decap_3
XTAP_TAPCELL_ROW_16_439 VGND VPWR sky130_fd_sc_hd__tapvpwrvgnd_1
XFILLER_14_433 VGND VGND VPWR VPWR sky130_fd_sc_hd__decap_3
XFILLER_26_293 VGND VGND VPWR VPWR sky130_fd_sc_hd__fill_2
XFILLER_41_241 VGND VGND VPWR VPWR sky130_fd_sc_hd__decap_3
XFILLER_53_30 VGND VGND VPWR VPWR sky130_fd_sc_hd__decap_3
XFILLER_53_63 VGND VGND VPWR VPWR sky130_fd_sc_hd__decap_3
XFILLER_14_477 VGND VGND VPWR VPWR sky130_fd_sc_hd__fill_2
XFILLER_41_274 VGND VGND VPWR VPWR sky130_fd_sc_hd__decap_3
XFILLER_41_296 VGND VGND VPWR VPWR sky130_fd_sc_hd__decap_3
XFILLER_5_131 VGND VGND VPWR VPWR sky130_fd_sc_hd__decap_3
XFILLER_5_164 VGND VGND VPWR VPWR sky130_fd_sc_hd__decap_3
XTAP_TAPCELL_ROW_114_1622 VGND VPWR sky130_fd_sc_hd__tapvpwrvgnd_1
XFILLER_108_582 VGND VGND VPWR VPWR sky130_fd_sc_hd__decap_3
XFILLER_5_175 VGND VGND VPWR VPWR sky130_fd_sc_hd__decap_3
XFILLER_69_617 VGND VGND VPWR VPWR sky130_fd_sc_hd__decap_3
XFILLER_78_60 VGND VGND VPWR VPWR sky130_fd_sc_hd__decap_3
XFILLER_96_403 VGND VGND VPWR VPWR sky130_fd_sc_hd__decap_3
XFILLER_38_6 VGND VGND VPWR VPWR sky130_fd_sc_hd__decap_3
XFILLER_68_116 VGND VGND VPWR VPWR sky130_fd_sc_hd__decap_3
XFILLER_49_330 VGND VGND VPWR VPWR sky130_fd_sc_hd__decap_3
XFILLER_37_514 VGND VGND VPWR VPWR sky130_fd_sc_hd__decap_3
XFILLER_49_352 VGND VGND VPWR VPWR sky130_fd_sc_hd__decap_3
XFILLER_64_344 VGND VGND VPWR VPWR sky130_fd_sc_hd__fill_1
XFILLER_76_171 VGND VGND VPWR VPWR sky130_fd_sc_hd__fill_2
XFILLER_94_81 VGND VGND VPWR VPWR sky130_fd_sc_hd__decap_3
XFILLER_52_517 VGND VGND VPWR VPWR sky130_fd_sc_hd__decap_3
XFILLER_64_377 VGND VGND VPWR VPWR sky130_fd_sc_hd__decap_3
XFILLER_17_271 VGND VGND VPWR VPWR sky130_fd_sc_hd__decap_3
X_4941_ _5103_/A1 _4936_/Y _4940_/Y VGND VGND VPWR VPWR _5657_/C sky130_fd_sc_hd__a21o_2
XFILLER_32_241 VGND VGND VPWR VPWR sky130_fd_sc_hd__decap_3
X_4872_ _4872_/A _4872_/B VGND VGND VPWR VPWR _4872_/X sky130_fd_sc_hd__and2_2
XFILLER_20_403 VGND VGND VPWR VPWR sky130_fd_sc_hd__fill_1
X_6611_ _6611_/A VGND VGND VPWR VPWR _6611_/Y sky130_fd_sc_hd__inv_2
X_3823_ _6947_/Q _3826_/A2 _3912_/B1 _6959_/Q VGND VGND VPWR VPWR _3823_/X sky130_fd_sc_hd__a22o_2
XTAP_TAPCELL_ROW_43_770 VGND VPWR sky130_fd_sc_hd__tapvpwrvgnd_1
X_6542_ _6548_/A VGND VGND VPWR VPWR _6542_/Y sky130_fd_sc_hd__inv_2
X_3754_ _3754_/A1 _3757_/S _3753_/X VGND VGND VPWR VPWR _7397_/D sky130_fd_sc_hd__o21a_2
X_6473_ _6473_/A VGND VGND VPWR VPWR _6473_/Y sky130_fd_sc_hd__inv_2
XFILLER_106_508 VGND VGND VPWR VPWR sky130_fd_sc_hd__decap_3
XFILLER_114_552 VGND VGND VPWR VPWR sky130_fd_sc_hd__fill_1
XFILLER_99_252 VGND VGND VPWR VPWR sky130_fd_sc_hd__decap_3
XFILLER_101_213 VGND VGND VPWR VPWR sky130_fd_sc_hd__decap_3
XFILLER_59_116 VGND VGND VPWR VPWR sky130_fd_sc_hd__decap_3
X_5286_ _5286_/A0 _5139_/X _5292_/S VGND VGND VPWR VPWR _7186_/D sky130_fd_sc_hd__mux2_2
X_4306_ _7288_/Q _5136_/S _3417_/X _7096_/Q VGND VGND VPWR VPWR _4311_/A sky130_fd_sc_hd__a22o_2
XFILLER_99_296 VGND VGND VPWR VPWR sky130_fd_sc_hd__decap_3
XFILLER_101_257 VGND VGND VPWR VPWR sky130_fd_sc_hd__decap_3
XFILLER_75_609 VGND VGND VPWR VPWR sky130_fd_sc_hd__decap_3
X_7025_ _7338_/CLK _7025_/D _6305_/Y VGND VGND VPWR VPWR _7025_/Q sky130_fd_sc_hd__dfrtp_2
X_4237_ _7259_/Q _3358_/X _4236_/X VGND VGND VPWR VPWR _4237_/X sky130_fd_sc_hd__a21o_2
XFILLER_101_279 VGND VGND VPWR VPWR sky130_fd_sc_hd__fill_1
XFILLER_68_683 VGND VGND VPWR VPWR sky130_fd_sc_hd__fill_1
XFILLER_28_536 VGND VGND VPWR VPWR sky130_fd_sc_hd__fill_2
XFILLER_28_558 VGND VGND VPWR VPWR sky130_fd_sc_hd__decap_3
XFILLER_55_333 VGND VGND VPWR VPWR sky130_fd_sc_hd__decap_3
XFILLER_74_29 VGND VGND VPWR VPWR sky130_fd_sc_hd__decap_3
XFILLER_83_620 VGND VGND VPWR VPWR sky130_fd_sc_hd__decap_3
XFILLER_83_631 VGND VGND VPWR VPWR sky130_fd_sc_hd__decap_3
XFILLER_95_491 VGND VGND VPWR VPWR sky130_fd_sc_hd__decap_3
X_4168_ _7046_/Q _4486_/S _4394_/B _7361_/Q _4167_/X VGND VGND VPWR VPWR _4168_/X
+ sky130_fd_sc_hd__a221o_2
XFILLER_43_517 VGND VGND VPWR VPWR sky130_fd_sc_hd__decap_3
XFILLER_55_355 VGND VGND VPWR VPWR sky130_fd_sc_hd__decap_3
XFILLER_70_303 VGND VGND VPWR VPWR sky130_fd_sc_hd__decap_3
XFILLER_82_141 VGND VGND VPWR VPWR sky130_fd_sc_hd__decap_3
XFILLER_83_664 VGND VGND VPWR VPWR sky130_fd_sc_hd__fill_2
X_4099_ _7301_/Q _4501_/S _4430_/B1 _7173_/Q _4098_/X VGND VGND VPWR VPWR _4099_/X
+ sky130_fd_sc_hd__a221o_2
XFILLER_82_174 VGND VGND VPWR VPWR sky130_fd_sc_hd__decap_3
XFILLER_70_347 VGND VGND VPWR VPWR sky130_fd_sc_hd__decap_3
XFILLER_90_17 VGND VGND VPWR VPWR sky130_fd_sc_hd__decap_3
XFILLER_11_414 VGND VGND VPWR VPWR sky130_fd_sc_hd__decap_3
X_6809_ _6968_/CLK _6809_/D VGND VGND VPWR VPWR _6809_/Q sky130_fd_sc_hd__dfxtp_2
XTAP_TAPCELL_ROW_13_409 VGND VPWR sky130_fd_sc_hd__tapvpwrvgnd_1
XPHY_EDGE_ROW_83_Left_200 VGND VGND VPWR VPWR sky130_fd_sc_hd__decap_3
XFILLER_23_33 VGND VGND VPWR VPWR sky130_fd_sc_hd__decap_3
XFILLER_109_313 VGND VGND VPWR VPWR sky130_fd_sc_hd__decap_3
XFILLER_11_469 VGND VGND VPWR VPWR sky130_fd_sc_hd__decap_3
XFILLER_23_66 VGND VGND VPWR VPWR sky130_fd_sc_hd__decap_3
XFILLER_7_407 VGND VGND VPWR VPWR sky130_fd_sc_hd__fill_2
XFILLER_109_346 VGND VGND VPWR VPWR sky130_fd_sc_hd__decap_3
XFILLER_109_379 VGND VGND VPWR VPWR sky130_fd_sc_hd__decap_3
XFILLER_3_3 VGND VGND VPWR VPWR sky130_fd_sc_hd__decap_3
XFILLER_2_167 VGND VGND VPWR VPWR sky130_fd_sc_hd__fill_1
XFILLER_2_189 VGND VGND VPWR VPWR sky130_fd_sc_hd__decap_3
XFILLER_78_425 VGND VGND VPWR VPWR sky130_fd_sc_hd__decap_3
XFILLER_48_41 VGND VGND VPWR VPWR sky130_fd_sc_hd__decap_3
XFILLER_78_458 VGND VGND VPWR VPWR sky130_fd_sc_hd__decap_3
XFILLER_65_119 VGND VGND VPWR VPWR sky130_fd_sc_hd__decap_3
XFILLER_93_417 VGND VGND VPWR VPWR sky130_fd_sc_hd__decap_3
XFILLER_58_171 VGND VGND VPWR VPWR sky130_fd_sc_hd__decap_3
XFILLER_86_480 VGND VGND VPWR VPWR sky130_fd_sc_hd__decap_3
XFILLER_104_80 VGND VGND VPWR VPWR sky130_fd_sc_hd__decap_3
XFILLER_34_517 VGND VGND VPWR VPWR sky130_fd_sc_hd__fill_2
XFILLER_46_377 VGND VGND VPWR VPWR sky130_fd_sc_hd__decap_3
XTAP_TAPCELL_ROW_29_597 VGND VPWR sky130_fd_sc_hd__tapvpwrvgnd_1
XFILLER_61_358 VGND VGND VPWR VPWR sky130_fd_sc_hd__decap_3
XFILLER_73_196 VGND VGND VPWR VPWR sky130_fd_sc_hd__decap_3
XTAP_TAPCELL_ROW_64_1020 VGND VPWR sky130_fd_sc_hd__tapvpwrvgnd_1
XFILLER_14_296 VGND VGND VPWR VPWR sky130_fd_sc_hd__decap_3
XFILLER_80_50 VGND VGND VPWR VPWR sky130_fd_sc_hd__decap_3
XFILLER_9_57 VGND VGND VPWR VPWR sky130_fd_sc_hd__fill_2
XFILLER_80_94 VGND VGND VPWR VPWR sky130_fd_sc_hd__fill_2
XFILLER_6_451 VGND VGND VPWR VPWR sky130_fd_sc_hd__decap_3
Xhold908 _7093_/Q VGND VGND VPWR VPWR _7093_/D sky130_fd_sc_hd__dlygate4sd3_1
Xhold919 _6708_/Q VGND VGND VPWR VPWR hold919/X sky130_fd_sc_hd__dlygate4sd3_1
X_3470_ _3468_/X _3424_/S _4537_/C _4537_/B VGND VGND VPWR VPWR _3545_/B sky130_fd_sc_hd__o2bb2a_2
XFILLER_89_81 VGND VGND VPWR VPWR sky130_fd_sc_hd__decap_3
XFILLER_36_3 VGND VGND VPWR VPWR sky130_fd_sc_hd__decap_3
XFILLER_69_414 VGND VGND VPWR VPWR sky130_fd_sc_hd__decap_3
XFILLER_96_200 VGND VGND VPWR VPWR sky130_fd_sc_hd__decap_3
X_5140_ _5140_/A0 _5139_/X _5159_/S VGND VGND VPWR VPWR _7250_/D sky130_fd_sc_hd__mux2_2
XFILLER_69_447 VGND VGND VPWR VPWR sky130_fd_sc_hd__fill_1
X_5071_ _5071_/A _5071_/B VGND VGND VPWR VPWR _5072_/C sky130_fd_sc_hd__nand2_2
XFILLER_56_119 VGND VGND VPWR VPWR sky130_fd_sc_hd__decap_3
XFILLER_84_417 VGND VGND VPWR VPWR sky130_fd_sc_hd__decap_3
XFILLER_96_277 VGND VGND VPWR VPWR sky130_fd_sc_hd__decap_3
XFILLER_37_311 VGND VGND VPWR VPWR sky130_fd_sc_hd__decap_3
XFILLER_37_322 VGND VGND VPWR VPWR sky130_fd_sc_hd__decap_3
XFILLER_64_141 VGND VGND VPWR VPWR sky130_fd_sc_hd__fill_1
XFILLER_65_664 VGND VGND VPWR VPWR sky130_fd_sc_hd__decap_3
XFILLER_80_601 VGND VGND VPWR VPWR sky130_fd_sc_hd__decap_3
XFILLER_92_461 VGND VGND VPWR VPWR sky130_fd_sc_hd__decap_3
XFILLER_37_399 VGND VGND VPWR VPWR sky130_fd_sc_hd__fill_1
XFILLER_64_163 VGND VGND VPWR VPWR sky130_fd_sc_hd__decap_3
XFILLER_92_483 VGND VGND VPWR VPWR sky130_fd_sc_hd__decap_3
XFILLER_52_336 VGND VGND VPWR VPWR sky130_fd_sc_hd__decap_3
XFILLER_80_645 VGND VGND VPWR VPWR sky130_fd_sc_hd__decap_3
X_4924_ _4920_/A _4922_/X _4923_/Y VGND VGND VPWR VPWR _4924_/X sky130_fd_sc_hd__a21o_2
XFILLER_100_38 VGND VGND VPWR VPWR sky130_fd_sc_hd__decap_3
XFILLER_20_233 VGND VGND VPWR VPWR sky130_fd_sc_hd__decap_3
XFILLER_60_391 VGND VGND VPWR VPWR sky130_fd_sc_hd__decap_3
X_4855_ _4855_/A _4855_/B _4854_/X VGND VGND VPWR VPWR _5655_/D sky130_fd_sc_hd__or3b_4
X_4786_ _4795_/A _4795_/B _4648_/A VGND VGND VPWR VPWR _4787_/B sky130_fd_sc_hd__a21o_2
X_3806_ _6966_/Q _3869_/A2 _3825_/B1 _6954_/Q _3805_/X VGND VGND VPWR VPWR _3806_/X
+ sky130_fd_sc_hd__a221o_2
X_6525_ _6585_/A VGND VGND VPWR VPWR _6525_/Y sky130_fd_sc_hd__inv_2
X_3737_ _6752_/Q _3912_/A2 _3888_/B1 _6746_/Q VGND VGND VPWR VPWR _3737_/X sky130_fd_sc_hd__a22o_2
XFILLER_106_327 VGND VGND VPWR VPWR sky130_fd_sc_hd__decap_3
XFILLER_109_69 VGND VGND VPWR VPWR sky130_fd_sc_hd__decap_3
XFILLER_69_18 VGND VGND VPWR VPWR sky130_fd_sc_hd__decap_3
X_6456_ _6616_/A VGND VGND VPWR VPWR _6456_/Y sky130_fd_sc_hd__inv_2
X_3668_ _6943_/Q _3828_/A2 _3827_/B1 _6895_/Q VGND VGND VPWR VPWR _3668_/X sky130_fd_sc_hd__a22o_2
X_6387_ _6578_/A VGND VGND VPWR VPWR _6387_/Y sky130_fd_sc_hd__inv_2
X_5407_ _5407_/A0 _5061_/X _5419_/S VGND VGND VPWR VPWR _7130_/D sky130_fd_sc_hd__mux2_2
X_3599_ _3599_/A _3600_/A VGND VGND VPWR VPWR _4614_/C sky130_fd_sc_hd__nor2_2
XFILLER_102_511 VGND VGND VPWR VPWR sky130_fd_sc_hd__decap_3
XFILLER_87_200 VGND VGND VPWR VPWR sky130_fd_sc_hd__decap_3
X_5338_ _5338_/A0 _5061_/X _5360_/S VGND VGND VPWR VPWR _7162_/D sky130_fd_sc_hd__mux2_2
XFILLER_102_533 VGND VGND VPWR VPWR sky130_fd_sc_hd__fill_2
XFILLER_114_382 VGND VGND VPWR VPWR sky130_fd_sc_hd__decap_3
XFILLER_85_17 VGND VGND VPWR VPWR sky130_fd_sc_hd__decap_3
XFILLER_87_244 VGND VGND VPWR VPWR sky130_fd_sc_hd__decap_3
X_7008_ _7368_/CLK _7008_/D _6288_/Y VGND VGND VPWR VPWR _7008_/Q sky130_fd_sc_hd__dfrtp_2
XTAP_TAPCELL_ROW_89_1318 VGND VPWR sky130_fd_sc_hd__tapvpwrvgnd_1
XFILLER_28_333 VGND VGND VPWR VPWR sky130_fd_sc_hd__decap_3
XFILLER_68_480 VGND VGND VPWR VPWR sky130_fd_sc_hd__decap_3
XFILLER_68_491 VGND VGND VPWR VPWR sky130_fd_sc_hd__decap_3
XFILLER_75_439 VGND VGND VPWR VPWR sky130_fd_sc_hd__decap_3
XFILLER_87_299 VGND VGND VPWR VPWR sky130_fd_sc_hd__decap_3
XFILLER_18_55 VGND VGND VPWR VPWR sky130_fd_sc_hd__decap_3
XFILLER_55_141 VGND VGND VPWR VPWR sky130_fd_sc_hd__decap_3
XFILLER_71_601 VGND VGND VPWR VPWR sky130_fd_sc_hd__fill_2
XFILLER_18_88 VGND VGND VPWR VPWR sky130_fd_sc_hd__decap_3
XFILLER_43_314 VGND VGND VPWR VPWR sky130_fd_sc_hd__decap_3
XFILLER_55_163 VGND VGND VPWR VPWR sky130_fd_sc_hd__decap_3
XFILLER_70_111 VGND VGND VPWR VPWR sky130_fd_sc_hd__decap_3
XFILLER_71_623 VGND VGND VPWR VPWR sky130_fd_sc_hd__fill_2
XFILLER_83_494 VGND VGND VPWR VPWR sky130_fd_sc_hd__decap_3
XFILLER_70_144 VGND VGND VPWR VPWR sky130_fd_sc_hd__decap_3
XFILLER_34_54 VGND VGND VPWR VPWR sky130_fd_sc_hd__decap_3
XFILLER_70_166 VGND VGND VPWR VPWR sky130_fd_sc_hd__decap_3
XFILLER_71_689 VGND VGND VPWR VPWR sky130_fd_sc_hd__decap_3
XTAP_TAPCELL_ROW_54_898 VGND VPWR sky130_fd_sc_hd__tapvpwrvgnd_1
XTAP_TAPCELL_ROW_26_567 VGND VPWR sky130_fd_sc_hd__tapvpwrvgnd_1
XFILLER_51_380 VGND VGND VPWR VPWR sky130_fd_sc_hd__decap_3
XFILLER_11_255 VGND VGND VPWR VPWR sky130_fd_sc_hd__decap_3
XFILLER_11_299 VGND VGND VPWR VPWR sky130_fd_sc_hd__decap_3
XFILLER_109_154 VGND VGND VPWR VPWR sky130_fd_sc_hd__decap_3
XFILLER_50_64 VGND VGND VPWR VPWR sky130_fd_sc_hd__decap_3
XFILLER_7_259 VGND VGND VPWR VPWR sky130_fd_sc_hd__decap_3
XFILLER_109_176 VGND VGND VPWR VPWR sky130_fd_sc_hd__decap_3
XFILLER_3_410 VGND VGND VPWR VPWR sky130_fd_sc_hd__decap_3
XFILLER_3_443 VGND VGND VPWR VPWR sky130_fd_sc_hd__decap_3
XFILLER_78_200 VGND VGND VPWR VPWR sky130_fd_sc_hd__decap_3
XFILLER_105_382 VGND VGND VPWR VPWR sky130_fd_sc_hd__decap_3
XFILLER_105_393 VGND VGND VPWR VPWR sky130_fd_sc_hd__decap_3
XFILLER_22_9 VGND VGND VPWR VPWR sky130_fd_sc_hd__decap_3
XFILLER_115_90 VGND VGND VPWR VPWR sky130_fd_sc_hd__decap_3
XFILLER_19_311 VGND VGND VPWR VPWR sky130_fd_sc_hd__decap_3
XFILLER_66_439 VGND VGND VPWR VPWR sky130_fd_sc_hd__decap_3
XFILLER_93_225 VGND VGND VPWR VPWR sky130_fd_sc_hd__fill_2
XTAP_TAPCELL_ROW_70_1090 VGND VPWR sky130_fd_sc_hd__tapvpwrvgnd_1
XFILLER_46_130 VGND VGND VPWR VPWR sky130_fd_sc_hd__decap_3
XFILLER_46_141 VGND VGND VPWR VPWR sky130_fd_sc_hd__decap_3
XTAP_TAPCELL_ROW_109_1554 VGND VPWR sky130_fd_sc_hd__tapvpwrvgnd_1
XFILLER_19_399 VGND VGND VPWR VPWR sky130_fd_sc_hd__decap_3
XFILLER_46_185 VGND VGND VPWR VPWR sky130_fd_sc_hd__decap_3
XFILLER_74_461 VGND VGND VPWR VPWR sky130_fd_sc_hd__decap_3
XFILLER_75_83 VGND VGND VPWR VPWR sky130_fd_sc_hd__fill_1
XTAP_TAPCELL_ROW_109_1565 VGND VPWR sky130_fd_sc_hd__tapvpwrvgnd_1
XFILLER_34_336 VGND VGND VPWR VPWR sky130_fd_sc_hd__decap_3
XFILLER_61_111 VGND VGND VPWR VPWR sky130_fd_sc_hd__fill_1
XFILLER_62_645 VGND VGND VPWR VPWR sky130_fd_sc_hd__fill_2
XFILLER_62_656 VGND VGND VPWR VPWR sky130_fd_sc_hd__decap_3
XFILLER_62_667 VGND VGND VPWR VPWR sky130_fd_sc_hd__decap_3
XFILLER_61_155 VGND VGND VPWR VPWR sky130_fd_sc_hd__decap_3
XFILLER_91_60 VGND VGND VPWR VPWR sky130_fd_sc_hd__decap_3
XFILLER_30_531 VGND VGND VPWR VPWR sky130_fd_sc_hd__fill_1
XFILLER_61_199 VGND VGND VPWR VPWR sky130_fd_sc_hd__decap_3
X_4640_ _4938_/B _4918_/A VGND VGND VPWR VPWR _4640_/Y sky130_fd_sc_hd__nor2_2
X_6310_ _6634_/A VGND VGND VPWR VPWR _6310_/Y sky130_fd_sc_hd__inv_2
X_4571_ _4571_/A _4583_/B VGND VGND VPWR VPWR _7295_/D sky130_fd_sc_hd__and2_2
XFILLER_115_102 VGND VGND VPWR VPWR sky130_fd_sc_hd__decap_3
XFILLER_115_113 VGND VGND VPWR VPWR sky130_fd_sc_hd__fill_1
X_7290_ clkload2/A _7290_/D _6570_/Y VGND VGND VPWR VPWR _7290_/Q sky130_fd_sc_hd__dfrtp_2
Xhold705 _6738_/Q VGND VGND VPWR VPWR _6738_/D sky130_fd_sc_hd__dlygate4sd3_1
Xhold716 _6921_/Q VGND VGND VPWR VPWR _6921_/D sky130_fd_sc_hd__dlygate4sd3_1
Xhold727 _6754_/Q VGND VGND VPWR VPWR _6754_/D sky130_fd_sc_hd__dlygate4sd3_1
X_3522_ _5118_/C _4938_/A _3618_/C VGND VGND VPWR VPWR _3522_/Y sky130_fd_sc_hd__nand3_1
Xhold738 _6785_/Q VGND VGND VPWR VPWR _6785_/D sky130_fd_sc_hd__dlygate4sd3_1
Xhold749 _6837_/Q VGND VGND VPWR VPWR _6837_/D sky130_fd_sc_hd__dlygate4sd3_1
X_3453_ _7218_/Q _3318_/B _4332_/B1 _7378_/Q VGND VGND VPWR VPWR _3453_/X sky130_fd_sc_hd__a22o_2
XFILLER_103_308 VGND VGND VPWR VPWR sky130_fd_sc_hd__decap_3
XFILLER_97_520 VGND VGND VPWR VPWR sky130_fd_sc_hd__decap_3
XFILLER_111_330 VGND VGND VPWR VPWR sky130_fd_sc_hd__decap_3
XFILLER_69_222 VGND VGND VPWR VPWR sky130_fd_sc_hd__fill_2
X_3384_ _7315_/Q _3989_/S _4530_/S _7283_/Q VGND VGND VPWR VPWR _3384_/X sky130_fd_sc_hd__a22o_2
XFILLER_29_108 VGND VGND VPWR VPWR sky130_fd_sc_hd__decap_3
XFILLER_57_417 VGND VGND VPWR VPWR sky130_fd_sc_hd__decap_3
XFILLER_69_255 VGND VGND VPWR VPWR sky130_fd_sc_hd__decap_3
XFILLER_111_385 VGND VGND VPWR VPWR sky130_fd_sc_hd__decap_3
XFILLER_111_396 VGND VGND VPWR VPWR sky130_fd_sc_hd__decap_3
XFILLER_29_119 VGND VGND VPWR VPWR sky130_fd_sc_hd__decap_3
XFILLER_69_299 VGND VGND VPWR VPWR sky130_fd_sc_hd__decap_3
XFILLER_84_225 VGND VGND VPWR VPWR sky130_fd_sc_hd__decap_3
X_5054_ _5054_/A VGND VGND VPWR VPWR _5054_/Y sky130_fd_sc_hd__inv_2
XFILLER_25_314 VGND VGND VPWR VPWR sky130_fd_sc_hd__decap_3
XFILLER_37_152 VGND VGND VPWR VPWR sky130_fd_sc_hd__decap_3
XFILLER_111_37 VGND VGND VPWR VPWR sky130_fd_sc_hd__decap_3
XFILLER_25_358 VGND VGND VPWR VPWR sky130_fd_sc_hd__decap_3
XTAP_TAPCELL_ROW_84_1259 VGND VPWR sky130_fd_sc_hd__tapvpwrvgnd_1
XFILLER_40_306 VGND VGND VPWR VPWR sky130_fd_sc_hd__fill_2
XFILLER_52_144 VGND VGND VPWR VPWR sky130_fd_sc_hd__decap_3
XFILLER_52_177 VGND VGND VPWR VPWR sky130_fd_sc_hd__decap_3
XFILLER_71_19 VGND VGND VPWR VPWR sky130_fd_sc_hd__decap_3
XFILLER_80_486 VGND VGND VPWR VPWR sky130_fd_sc_hd__decap_3
XFILLER_40_339 VGND VGND VPWR VPWR sky130_fd_sc_hd__decap_3
X_4907_ _4948_/A _4888_/B _4903_/X _4906_/X VGND VGND VPWR VPWR _5657_/B sky130_fd_sc_hd__o31ai_4
XTAP_TAPCELL_ROW_23_526 VGND VPWR sky130_fd_sc_hd__tapvpwrvgnd_1
XTAP_TAPCELL_ROW_51_868 VGND VPWR sky130_fd_sc_hd__tapvpwrvgnd_1
XFILLER_107_614 VGND VGND VPWR VPWR sky130_fd_sc_hd__fill_2
X_4769_ _4969_/B _4741_/X _4761_/Y _4768_/Y VGND VGND VPWR VPWR _4769_/X sky130_fd_sc_hd__a31o_2
XFILLER_106_113 VGND VGND VPWR VPWR sky130_fd_sc_hd__decap_3
XFILLER_20_23 VGND VGND VPWR VPWR sky130_fd_sc_hd__decap_3
X_6508_ _6608_/A VGND VGND VPWR VPWR _6508_/Y sky130_fd_sc_hd__inv_2
XFILLER_105_6 VGND VGND VPWR VPWR sky130_fd_sc_hd__decap_3
XFILLER_20_56 VGND VGND VPWR VPWR sky130_fd_sc_hd__decap_3
X_6439_ _6532_/A VGND VGND VPWR VPWR _6439_/Y sky130_fd_sc_hd__inv_2
XTAP_TAPCELL_ROW_95_1388 VGND VPWR sky130_fd_sc_hd__tapvpwrvgnd_1
XFILLER_0_413 VGND VGND VPWR VPWR sky130_fd_sc_hd__decap_3
XFILLER_0_424 VGND VGND VPWR VPWR sky130_fd_sc_hd__fill_2
XFILLER_0_446 VGND VGND VPWR VPWR sky130_fd_sc_hd__fill_2
XFILLER_102_330 VGND VGND VPWR VPWR sky130_fd_sc_hd__decap_3
XFILLER_114_190 VGND VGND VPWR VPWR sky130_fd_sc_hd__decap_3
XFILLER_88_531 VGND VGND VPWR VPWR sky130_fd_sc_hd__fill_1
XFILLER_88_542 VGND VGND VPWR VPWR sky130_fd_sc_hd__decap_3
XFILLER_102_363 VGND VGND VPWR VPWR sky130_fd_sc_hd__fill_1
XFILLER_29_32 VGND VGND VPWR VPWR sky130_fd_sc_hd__decap_3
XFILLER_48_406 VGND VGND VPWR VPWR sky130_fd_sc_hd__fill_2
XFILLER_102_396 VGND VGND VPWR VPWR sky130_fd_sc_hd__decap_3
XFILLER_29_87 VGND VGND VPWR VPWR sky130_fd_sc_hd__decap_3
XFILLER_48_439 VGND VGND VPWR VPWR sky130_fd_sc_hd__decap_3
XFILLER_75_225 VGND VGND VPWR VPWR sky130_fd_sc_hd__decap_3
XFILLER_28_141 VGND VGND VPWR VPWR sky130_fd_sc_hd__decap_3
XFILLER_75_269 VGND VGND VPWR VPWR sky130_fd_sc_hd__decap_3
XTAP_TAPCELL_ROW_59_957 VGND VPWR sky130_fd_sc_hd__tapvpwrvgnd_1
XFILLER_45_20 VGND VGND VPWR VPWR sky130_fd_sc_hd__decap_3
XFILLER_45_31 VGND VGND VPWR VPWR sky130_fd_sc_hd__fill_2
XFILLER_56_483 VGND VGND VPWR VPWR sky130_fd_sc_hd__decap_3
XFILLER_90_228 VGND VGND VPWR VPWR sky130_fd_sc_hd__decap_3
Xplace409 _3383_/Y VGND VGND VPWR VPWR _4501_/S sky130_fd_sc_hd__buf_2
XTAP_TAPCELL_ROW_3_284 VGND VPWR sky130_fd_sc_hd__tapvpwrvgnd_1
XPHY_EDGE_ROW_11_Left_128 VGND VGND VPWR VPWR sky130_fd_sc_hd__decap_3
XFILLER_16_325 VGND VGND VPWR VPWR sky130_fd_sc_hd__decap_3
XFILLER_43_122 VGND VGND VPWR VPWR sky130_fd_sc_hd__decap_3
XFILLER_71_420 VGND VGND VPWR VPWR sky130_fd_sc_hd__fill_2
XFILLER_43_166 VGND VGND VPWR VPWR sky130_fd_sc_hd__fill_2
XFILLER_71_475 VGND VGND VPWR VPWR sky130_fd_sc_hd__decap_3
XFILLER_43_199 VGND VGND VPWR VPWR sky130_fd_sc_hd__decap_3
XFILLER_101_81 VGND VGND VPWR VPWR sky130_fd_sc_hd__decap_3
XFILLER_24_391 VGND VGND VPWR VPWR sky130_fd_sc_hd__decap_3
XFILLER_61_30 VGND VGND VPWR VPWR sky130_fd_sc_hd__decap_3
XTAP_TAPCELL_ROW_104_1495 VGND VPWR sky130_fd_sc_hd__tapvpwrvgnd_1
XFILLER_12_586 VGND VGND VPWR VPWR sky130_fd_sc_hd__fill_2
XFILLER_61_63 VGND VGND VPWR VPWR sky130_fd_sc_hd__decap_3
XANTENNA_7 _5633_/B VGND VGND VPWR VPWR sky130_fd_sc_hd__diode_2
XPHY_EDGE_ROW_20_Left_137 VGND VGND VPWR VPWR sky130_fd_sc_hd__decap_3
XFILLER_112_138 VGND VGND VPWR VPWR sky130_fd_sc_hd__fill_2
XFILLER_3_273 VGND VGND VPWR VPWR sky130_fd_sc_hd__decap_3
XFILLER_3_284 VGND VGND VPWR VPWR sky130_fd_sc_hd__decap_3
XFILLER_79_531 VGND VGND VPWR VPWR sky130_fd_sc_hd__fill_1
XFILLER_105_190 VGND VGND VPWR VPWR sky130_fd_sc_hd__fill_2
XFILLER_20_6 VGND VGND VPWR VPWR sky130_fd_sc_hd__fill_2
XFILLER_39_417 VGND VGND VPWR VPWR sky130_fd_sc_hd__decap_3
XFILLER_79_553 VGND VGND VPWR VPWR sky130_fd_sc_hd__decap_3
XFILLER_79_564 VGND VGND VPWR VPWR sky130_fd_sc_hd__fill_1
XFILLER_39_439 VGND VGND VPWR VPWR sky130_fd_sc_hd__decap_3
XFILLER_66_236 VGND VGND VPWR VPWR sky130_fd_sc_hd__decap_3
XFILLER_86_71 VGND VGND VPWR VPWR sky130_fd_sc_hd__decap_3
XFILLER_94_512 VGND VGND VPWR VPWR sky130_fd_sc_hd__decap_3
XFILLER_94_545 VGND VGND VPWR VPWR sky130_fd_sc_hd__decap_3
XFILLER_54_409 VGND VGND VPWR VPWR sky130_fd_sc_hd__decap_3
XFILLER_34_100 VGND VGND VPWR VPWR sky130_fd_sc_hd__fill_1
XFILLER_35_623 VGND VGND VPWR VPWR sky130_fd_sc_hd__fill_1
XFILLER_47_461 VGND VGND VPWR VPWR sky130_fd_sc_hd__decap_3
XFILLER_81_217 VGND VGND VPWR VPWR sky130_fd_sc_hd__decap_3
XFILLER_94_589 VGND VGND VPWR VPWR sky130_fd_sc_hd__decap_3
XFILLER_34_111 VGND VGND VPWR VPWR sky130_fd_sc_hd__decap_3
XFILLER_62_442 VGND VGND VPWR VPWR sky130_fd_sc_hd__decap_3
XFILLER_34_155 VGND VGND VPWR VPWR sky130_fd_sc_hd__decap_3
XFILLER_35_667 VGND VGND VPWR VPWR sky130_fd_sc_hd__decap_3
XFILLER_62_475 VGND VGND VPWR VPWR sky130_fd_sc_hd__fill_1
X_6790_ _6936_/CLK _6790_/D VGND VGND VPWR VPWR _6790_/Q sky130_fd_sc_hd__dfxtp_2
XFILLER_22_339 VGND VGND VPWR VPWR sky130_fd_sc_hd__decap_3
XFILLER_34_188 VGND VGND VPWR VPWR sky130_fd_sc_hd__decap_3
XFILLER_62_486 VGND VGND VPWR VPWR sky130_fd_sc_hd__decap_3
XFILLER_15_391 VGND VGND VPWR VPWR sky130_fd_sc_hd__fill_1
XFILLER_30_350 VGND VGND VPWR VPWR sky130_fd_sc_hd__decap_3
XFILLER_30_383 VGND VGND VPWR VPWR sky130_fd_sc_hd__decap_3
X_4623_ _4330_/B _4622_/X _5057_/B VGND VGND VPWR VPWR _4624_/A sky130_fd_sc_hd__o21ba_2
X_7342_ _7403_/CLK _7342_/D _6622_/Y VGND VGND VPWR VPWR _7342_/Q sky130_fd_sc_hd__dfrtp_2
X_4554_ _4554_/A _4569_/B VGND VGND VPWR VPWR _7303_/D sky130_fd_sc_hd__and2_2
XFILLER_116_433 VGND VGND VPWR VPWR sky130_fd_sc_hd__decap_3
XFILLER_116_455 VGND VGND VPWR VPWR sky130_fd_sc_hd__decap_3
X_7273_ _7307_/CLK _7273_/D _6553_/Y VGND VGND VPWR VPWR _7273_/Q sky130_fd_sc_hd__dfrtp_2
X_3505_ _3505_/A _3505_/B VGND VGND VPWR VPWR _3505_/X sky130_fd_sc_hd__or2_4
XFILLER_104_606 VGND VGND VPWR VPWR sky130_fd_sc_hd__decap_3
XFILLER_104_628 VGND VGND VPWR VPWR sky130_fd_sc_hd__decap_3
XFILLER_116_477 VGND VGND VPWR VPWR sky130_fd_sc_hd__decap_3
XFILLER_116_499 VGND VGND VPWR VPWR sky130_fd_sc_hd__decap_3
XFILLER_89_328 VGND VGND VPWR VPWR sky130_fd_sc_hd__decap_3
XFILLER_103_116 VGND VGND VPWR VPWR sky130_fd_sc_hd__decap_3
XFILLER_103_138 VGND VGND VPWR VPWR sky130_fd_sc_hd__decap_3
XFILLER_85_501 VGND VGND VPWR VPWR sky130_fd_sc_hd__decap_3
XFILLER_57_225 VGND VGND VPWR VPWR sky130_fd_sc_hd__decap_3
Xhold1202 _7324_/Q VGND VGND VPWR VPWR _4510_/A0 sky130_fd_sc_hd__dlygate4sd3_1
X_5106_ _6985_/Q _5068_/C _5577_/S VGND VGND VPWR VPWR _5106_/X sky130_fd_sc_hd__o21a_2
XFILLER_57_258 VGND VGND VPWR VPWR sky130_fd_sc_hd__decap_3
X_5037_ _6988_/Q _5045_/B VGND VGND VPWR VPWR _5038_/B sky130_fd_sc_hd__nand2_2
XFILLER_72_206 VGND VGND VPWR VPWR sky130_fd_sc_hd__decap_3
XFILLER_72_228 VGND VGND VPWR VPWR sky130_fd_sc_hd__decap_3
XTAP_TAPCELL_ROW_56_927 VGND VPWR sky130_fd_sc_hd__tapvpwrvgnd_1
XFILLER_25_111 VGND VGND VPWR VPWR sky130_fd_sc_hd__fill_1
XFILLER_25_122 VGND VGND VPWR VPWR sky130_fd_sc_hd__decap_3
XFILLER_26_645 VGND VGND VPWR VPWR sky130_fd_sc_hd__decap_3
XFILLER_26_656 VGND VGND VPWR VPWR sky130_fd_sc_hd__fill_2
XFILLER_82_29 VGND VGND VPWR VPWR sky130_fd_sc_hd__decap_3
XTAP_TAPCELL_ROW_0_254 VGND VPWR sky130_fd_sc_hd__tapvpwrvgnd_1
XTAP_TAPCELL_ROW_0_243 VGND VPWR sky130_fd_sc_hd__tapvpwrvgnd_1
XFILLER_13_306 VGND VGND VPWR VPWR sky130_fd_sc_hd__decap_3
XFILLER_15_12 VGND VGND VPWR VPWR sky130_fd_sc_hd__decap_3
XFILLER_25_155 VGND VGND VPWR VPWR sky130_fd_sc_hd__decap_3
XFILLER_53_475 VGND VGND VPWR VPWR sky130_fd_sc_hd__decap_3
XFILLER_15_45 VGND VGND VPWR VPWR sky130_fd_sc_hd__decap_3
XFILLER_25_199 VGND VGND VPWR VPWR sky130_fd_sc_hd__decap_3
XFILLER_80_283 VGND VGND VPWR VPWR sky130_fd_sc_hd__decap_3
X_6988_ _7396_/CLK _6988_/D _6268_/Y VGND VGND VPWR VPWR _6988_/Q sky130_fd_sc_hd__dfrtp_2
XTAP_TAPCELL_ROW_36_684 VGND VPWR sky130_fd_sc_hd__tapvpwrvgnd_1
XFILLER_15_89 VGND VGND VPWR VPWR sky130_fd_sc_hd__fill_1
XFILLER_40_136 VGND VGND VPWR VPWR sky130_fd_sc_hd__decap_3
XFILLER_40_147 VGND VGND VPWR VPWR sky130_fd_sc_hd__decap_3
XTAP_TAPCELL_ROW_97_1417 VGND VPWR sky130_fd_sc_hd__tapvpwrvgnd_1
XFILLER_31_77 VGND VGND VPWR VPWR sky130_fd_sc_hd__fill_1
XFILLER_5_538 VGND VGND VPWR VPWR sky130_fd_sc_hd__decap_3
XFILLER_107_455 VGND VGND VPWR VPWR sky130_fd_sc_hd__decap_3
XFILLER_103_3 VGND VGND VPWR VPWR sky130_fd_sc_hd__decap_3
XTAP_TAPCELL_ROW_8_343 VGND VPWR sky130_fd_sc_hd__tapvpwrvgnd_1
XFILLER_103_661 VGND VGND VPWR VPWR sky130_fd_sc_hd__fill_1
XFILLER_76_501 VGND VGND VPWR VPWR sky130_fd_sc_hd__decap_3
XFILLER_88_350 VGND VGND VPWR VPWR sky130_fd_sc_hd__decap_3
XFILLER_48_203 VGND VGND VPWR VPWR sky130_fd_sc_hd__fill_2
XFILLER_88_383 VGND VGND VPWR VPWR sky130_fd_sc_hd__decap_3
XFILLER_0_298 VGND VGND VPWR VPWR sky130_fd_sc_hd__decap_3
XFILLER_48_247 VGND VGND VPWR VPWR sky130_fd_sc_hd__decap_3
XFILLER_56_41 VGND VGND VPWR VPWR sky130_fd_sc_hd__decap_3
XFILLER_76_545 VGND VGND VPWR VPWR sky130_fd_sc_hd__fill_2
XFILLER_76_567 VGND VGND VPWR VPWR sky130_fd_sc_hd__decap_3
XFILLER_56_74 VGND VGND VPWR VPWR sky130_fd_sc_hd__decap_3
XFILLER_16_122 VGND VGND VPWR VPWR sky130_fd_sc_hd__decap_3
XFILLER_56_280 VGND VGND VPWR VPWR sky130_fd_sc_hd__decap_3
XFILLER_56_85 VGND VGND VPWR VPWR sky130_fd_sc_hd__decap_3
XFILLER_91_548 VGND VGND VPWR VPWR sky130_fd_sc_hd__decap_3
XTAP_TAPCELL_ROW_106_1524 VGND VPWR sky130_fd_sc_hd__tapvpwrvgnd_1
XFILLER_16_144 VGND VGND VPWR VPWR sky130_fd_sc_hd__decap_3
XFILLER_44_453 VGND VGND VPWR VPWR sky130_fd_sc_hd__decap_3
XFILLER_16_177 VGND VGND VPWR VPWR sky130_fd_sc_hd__decap_3
XFILLER_31_125 VGND VGND VPWR VPWR sky130_fd_sc_hd__decap_3
XFILLER_44_486 VGND VGND VPWR VPWR sky130_fd_sc_hd__decap_3
XFILLER_71_261 VGND VGND VPWR VPWR sky130_fd_sc_hd__decap_3
XFILLER_72_62 VGND VGND VPWR VPWR sky130_fd_sc_hd__fill_2
XFILLER_12_383 VGND VGND VPWR VPWR sky130_fd_sc_hd__decap_3
XFILLER_8_365 VGND VGND VPWR VPWR sky130_fd_sc_hd__decap_3
XFILLER_113_414 VGND VGND VPWR VPWR sky130_fd_sc_hd__decap_3
XFILLER_99_615 VGND VGND VPWR VPWR sky130_fd_sc_hd__fill_1
XFILLER_113_447 VGND VGND VPWR VPWR sky130_fd_sc_hd__fill_1
X_4270_ _7358_/Q _4270_/B VGND VGND VPWR VPWR _4270_/Y sky130_fd_sc_hd__nand2_2
XFILLER_98_169 VGND VGND VPWR VPWR sky130_fd_sc_hd__fill_2
XFILLER_97_92 VGND VGND VPWR VPWR sky130_fd_sc_hd__decap_3
XFILLER_100_108 VGND VGND VPWR VPWR sky130_fd_sc_hd__decap_3
XFILLER_67_523 VGND VGND VPWR VPWR sky130_fd_sc_hd__decap_3
XFILLER_79_372 VGND VGND VPWR VPWR sky130_fd_sc_hd__decap_3
XFILLER_39_247 VGND VGND VPWR VPWR sky130_fd_sc_hd__decap_3
XFILLER_67_556 VGND VGND VPWR VPWR sky130_fd_sc_hd__decap_3
XFILLER_94_342 VGND VGND VPWR VPWR sky130_fd_sc_hd__decap_3
XFILLER_39_269 VGND VGND VPWR VPWR sky130_fd_sc_hd__decap_3
XFILLER_54_206 VGND VGND VPWR VPWR sky130_fd_sc_hd__decap_3
XFILLER_54_239 VGND VGND VPWR VPWR sky130_fd_sc_hd__decap_3
XFILLER_82_559 VGND VGND VPWR VPWR sky130_fd_sc_hd__decap_3
X_6911_ _6929_/CLK _6911_/D VGND VGND VPWR VPWR _6911_/Q sky130_fd_sc_hd__dfxtp_2
X_6842_ _6967_/CLK _6842_/D VGND VGND VPWR VPWR _6842_/Q sky130_fd_sc_hd__dfxtp_2
XFILLER_22_103 VGND VGND VPWR VPWR sky130_fd_sc_hd__decap_3
XTAP_TAPCELL_ROW_81_1229 VGND VPWR sky130_fd_sc_hd__tapvpwrvgnd_1
XTAP_TAPCELL_ROW_81_1218 VGND VPWR sky130_fd_sc_hd__tapvpwrvgnd_1
XFILLER_22_147 VGND VGND VPWR VPWR sky130_fd_sc_hd__decap_3
X_6773_ _7351_/CLK _6773_/D VGND VGND VPWR VPWR _6773_/Q sky130_fd_sc_hd__dfxtp_2
X_3985_ _7348_/Q _4526_/A0 _3989_/S VGND VGND VPWR VPWR _7348_/D sky130_fd_sc_hd__mux2_2
XTAP_TAPCELL_ROW_33_643 VGND VPWR sky130_fd_sc_hd__tapvpwrvgnd_1
XFILLER_10_309 VGND VGND VPWR VPWR sky130_fd_sc_hd__decap_3
XTAP_TAPCELL_ROW_61_985 VGND VPWR sky130_fd_sc_hd__tapvpwrvgnd_1
XFILLER_30_180 VGND VGND VPWR VPWR sky130_fd_sc_hd__decap_3
X_5655_ _5655_/A _5655_/B _5655_/C _5655_/D VGND VGND VPWR VPWR _5665_/B sky130_fd_sc_hd__nor4_2
XFILLER_108_208 VGND VGND VPWR VPWR sky130_fd_sc_hd__decap_3
X_4606_ _5666_/A _5633_/B VGND VGND VPWR VPWR _4606_/Y sky130_fd_sc_hd__nor2_2
X_7325_ _7360_/CLK _7325_/D _6605_/Y VGND VGND VPWR VPWR _7325_/Q sky130_fd_sc_hd__dfrtp_2
X_5586_ hold977/X _5577_/S _5118_/X VGND VGND VPWR VPWR _7035_/D sky130_fd_sc_hd__o21a_2
XFILLER_104_403 VGND VGND VPWR VPWR sky130_fd_sc_hd__decap_3
X_4537_ _5118_/A _4537_/B _4537_/C VGND VGND VPWR VPWR _4567_/B sky130_fd_sc_hd__or3_2
XFILLER_104_436 VGND VGND VPWR VPWR sky130_fd_sc_hd__decap_3
XFILLER_77_18 VGND VGND VPWR VPWR sky130_fd_sc_hd__decap_3
XFILLER_89_125 VGND VGND VPWR VPWR sky130_fd_sc_hd__fill_2
XFILLER_89_136 VGND VGND VPWR VPWR sky130_fd_sc_hd__decap_3
X_7256_ clkload9/A _7256_/D _6536_/Y VGND VGND VPWR VPWR _7256_/Q sky130_fd_sc_hd__dfrtp_2
X_4468_ _7009_/Q _5152_/B _5577_/S VGND VGND VPWR VPWR _4468_/X sky130_fd_sc_hd__o21a_2
XTAP_TAPCELL_ROW_92_1358 VGND VPWR sky130_fd_sc_hd__tapvpwrvgnd_1
XFILLER_89_169 VGND VGND VPWR VPWR sky130_fd_sc_hd__fill_2
X_7187_ clkload1/A _7187_/D _6467_/Y VGND VGND VPWR VPWR _7187_/Q sky130_fd_sc_hd__dfrtp_2
X_3419_ _7123_/Q _3407_/X _3413_/X _3418_/X VGND VGND VPWR VPWR _3419_/Y sky130_fd_sc_hd__a211oi_2
XTAP_TAPCELL_ROW_5_313 VGND VPWR sky130_fd_sc_hd__tapvpwrvgnd_1
XFILLER_112_480 VGND VGND VPWR VPWR sky130_fd_sc_hd__decap_3
X_4399_ _7370_/Q _4399_/A2 _4398_/X _4429_/C1 VGND VGND VPWR VPWR _4399_/X sky130_fd_sc_hd__a211o_2
XFILLER_100_631 VGND VGND VPWR VPWR sky130_fd_sc_hd__decap_3
XFILLER_58_545 VGND VGND VPWR VPWR sky130_fd_sc_hd__fill_1
XFILLER_85_331 VGND VGND VPWR VPWR sky130_fd_sc_hd__decap_3
Xhold1010 _7196_/Q VGND VGND VPWR VPWR _5268_/A0 sky130_fd_sc_hd__dlygate4sd3_1
Xhold1021 _7039_/Q VGND VGND VPWR VPWR _5579_/A0 sky130_fd_sc_hd__dlygate4sd3_1
Xhold1032 _7293_/Q VGND VGND VPWR VPWR _4575_/A sky130_fd_sc_hd__dlygate4sd3_1
XFILLER_45_206 VGND VGND VPWR VPWR sky130_fd_sc_hd__decap_3
XFILLER_58_589 VGND VGND VPWR VPWR sky130_fd_sc_hd__fill_2
XFILLER_73_526 VGND VGND VPWR VPWR sky130_fd_sc_hd__decap_3
XFILLER_85_364 VGND VGND VPWR VPWR sky130_fd_sc_hd__decap_3
XFILLER_85_386 VGND VGND VPWR VPWR sky130_fd_sc_hd__decap_3
XFILLER_93_28 VGND VGND VPWR VPWR sky130_fd_sc_hd__decap_3
Xhold1043 _7279_/Q VGND VGND VPWR VPWR _4603_/A1 sky130_fd_sc_hd__dlygate4sd3_1
Xhold1054 _7213_/Q VGND VGND VPWR VPWR _5234_/A0 sky130_fd_sc_hd__dlygate4sd3_1
Xhold1065 _7275_/Q VGND VGND VPWR VPWR _4772_/A0 sky130_fd_sc_hd__dlygate4sd3_1
Xhold1076 _7245_/Q VGND VGND VPWR VPWR _5165_/A sky130_fd_sc_hd__dlygate4sd3_1
XFILLER_38_280 VGND VGND VPWR VPWR sky130_fd_sc_hd__decap_3
Xhold1087 _7402_/Q VGND VGND VPWR VPWR _3698_/A1 sky130_fd_sc_hd__dlygate4sd3_1
Xhold1098 _7256_/Q VGND VGND VPWR VPWR _5095_/A0 sky130_fd_sc_hd__dlygate4sd3_1
XFILLER_26_55 VGND VGND VPWR VPWR sky130_fd_sc_hd__decap_3
XFILLER_53_250 VGND VGND VPWR VPWR sky130_fd_sc_hd__decap_3
XFILLER_26_497 VGND VGND VPWR VPWR sky130_fd_sc_hd__fill_1
XFILLER_53_272 VGND VGND VPWR VPWR sky130_fd_sc_hd__decap_3
XFILLER_41_434 VGND VGND VPWR VPWR sky130_fd_sc_hd__fill_1
XFILLER_13_169 VGND VGND VPWR VPWR sky130_fd_sc_hd__decap_3
XFILLER_41_478 VGND VGND VPWR VPWR sky130_fd_sc_hd__decap_3
XFILLER_42_32 VGND VGND VPWR VPWR sky130_fd_sc_hd__decap_3
XTAP_TAPCELL_ROW_101_1465 VGND VPWR sky130_fd_sc_hd__tapvpwrvgnd_1
XFILLER_5_302 VGND VGND VPWR VPWR sky130_fd_sc_hd__decap_3
XFILLER_5_335 VGND VGND VPWR VPWR sky130_fd_sc_hd__fill_1
XFILLER_5_346 VGND VGND VPWR VPWR sky130_fd_sc_hd__decap_3
XFILLER_107_263 VGND VGND VPWR VPWR sky130_fd_sc_hd__decap_3
XFILLER_5_379 VGND VGND VPWR VPWR sky130_fd_sc_hd__decap_3
XFILLER_68_309 VGND VGND VPWR VPWR sky130_fd_sc_hd__decap_3
XFILLER_110_439 VGND VGND VPWR VPWR sky130_fd_sc_hd__decap_3
XFILLER_95_139 VGND VGND VPWR VPWR sky130_fd_sc_hd__decap_3
XTAP_TAPCELL_ROW_112_1594 VGND VPWR sky130_fd_sc_hd__tapvpwrvgnd_1
XFILLER_103_480 VGND VGND VPWR VPWR sky130_fd_sc_hd__decap_3
XFILLER_67_73 VGND VGND VPWR VPWR sky130_fd_sc_hd__decap_3
XFILLER_67_84 VGND VGND VPWR VPWR sky130_fd_sc_hd__fill_1
XFILLER_76_342 VGND VGND VPWR VPWR sky130_fd_sc_hd__fill_1
XFILLER_88_180 VGND VGND VPWR VPWR sky130_fd_sc_hd__fill_1
XFILLER_76_386 VGND VGND VPWR VPWR sky130_fd_sc_hd__decap_3
XFILLER_91_312 VGND VGND VPWR VPWR sky130_fd_sc_hd__decap_3
XFILLER_17_420 VGND VGND VPWR VPWR sky130_fd_sc_hd__fill_2
XFILLER_17_431 VGND VGND VPWR VPWR sky130_fd_sc_hd__decap_3
XFILLER_36_239 VGND VGND VPWR VPWR sky130_fd_sc_hd__decap_3
XFILLER_64_548 VGND VGND VPWR VPWR sky130_fd_sc_hd__decap_3
XFILLER_51_209 VGND VGND VPWR VPWR sky130_fd_sc_hd__decap_3
XFILLER_91_367 VGND VGND VPWR VPWR sky130_fd_sc_hd__decap_3
XTAP_TAPCELL_ROW_67_1051 VGND VPWR sky130_fd_sc_hd__tapvpwrvgnd_1
XPHY_EDGE_ROW_103_Left_220 VGND VGND VPWR VPWR sky130_fd_sc_hd__decap_3
XFILLER_44_283 VGND VGND VPWR VPWR sky130_fd_sc_hd__decap_3
XFILLER_83_83 VGND VGND VPWR VPWR sky130_fd_sc_hd__decap_3
XFILLER_32_456 VGND VGND VPWR VPWR sky130_fd_sc_hd__decap_3
X_3770_ _3770_/A1 _4791_/A1 _4944_/B VGND VGND VPWR VPWR _7393_/D sky130_fd_sc_hd__a21o_2
XTAP_TAPCELL_ROW_30_613 VGND VPWR sky130_fd_sc_hd__tapvpwrvgnd_1
XFILLER_13_681 VGND VGND VPWR VPWR sky130_fd_sc_hd__decap_3
XFILLER_8_162 VGND VGND VPWR VPWR sky130_fd_sc_hd__decap_3
XFILLER_66_3 VGND VGND VPWR VPWR sky130_fd_sc_hd__decap_3
XFILLER_8_195 VGND VGND VPWR VPWR sky130_fd_sc_hd__fill_1
XTAP_TAPCELL_ROW_10_370 VGND VPWR sky130_fd_sc_hd__tapvpwrvgnd_1
X_5371_ _7147_/Q _4771_/X _5383_/S VGND VGND VPWR VPWR _7147_/D sky130_fd_sc_hd__mux2_2
XFILLER_113_222 VGND VGND VPWR VPWR sky130_fd_sc_hd__fill_2
X_7110_ _7365_/CLK _7110_/D _6390_/Y VGND VGND VPWR VPWR _7110_/Q sky130_fd_sc_hd__dfrtp_2
X_4322_ _7290_/Q _5080_/S _3409_/X _7162_/Q _4321_/X VGND VGND VPWR VPWR _4322_/X
+ sky130_fd_sc_hd__a221o_2
XTAP_TAPCELL_ROW_78_1191 VGND VPWR sky130_fd_sc_hd__tapvpwrvgnd_1
XFILLER_99_423 VGND VGND VPWR VPWR sky130_fd_sc_hd__decap_3
X_7041_ _7394_/CLK _7041_/D _6321_/Y VGND VGND VPWR VPWR _7041_/Q sky130_fd_sc_hd__dfrtp_2
X_4253_ _7389_/Q _3380_/Y _5080_/S _7293_/Q _4252_/X VGND VGND VPWR VPWR _4253_/X
+ sky130_fd_sc_hd__a221o_2
XFILLER_99_467 VGND VGND VPWR VPWR sky130_fd_sc_hd__decap_3
XFILLER_113_277 VGND VGND VPWR VPWR sky130_fd_sc_hd__decap_3
XFILLER_113_299 VGND VGND VPWR VPWR sky130_fd_sc_hd__decap_3
XFILLER_67_331 VGND VGND VPWR VPWR sky130_fd_sc_hd__decap_3
XFILLER_86_139 VGND VGND VPWR VPWR sky130_fd_sc_hd__fill_1
X_4184_ _7296_/Q _5028_/S _4218_/A2 _7104_/Q _4183_/X VGND VGND VPWR VPWR _4185_/C
+ sky130_fd_sc_hd__a221o_2
XFILLER_67_364 VGND VGND VPWR VPWR sky130_fd_sc_hd__fill_2
XFILLER_95_673 VGND VGND VPWR VPWR sky130_fd_sc_hd__decap_3
XTAP_TAPCELL_ROW_38_713 VGND VPWR sky130_fd_sc_hd__tapvpwrvgnd_1
XTAP_TAPCELL_ROW_38_702 VGND VPWR sky130_fd_sc_hd__tapvpwrvgnd_1
XFILLER_103_27 VGND VGND VPWR VPWR sky130_fd_sc_hd__fill_2
XFILLER_27_228 VGND VGND VPWR VPWR sky130_fd_sc_hd__decap_3
XFILLER_67_386 VGND VGND VPWR VPWR sky130_fd_sc_hd__decap_3
XFILLER_82_312 VGND VGND VPWR VPWR sky130_fd_sc_hd__fill_2
XFILLER_82_334 VGND VGND VPWR VPWR sky130_fd_sc_hd__decap_3
XFILLER_94_183 VGND VGND VPWR VPWR sky130_fd_sc_hd__decap_3
XFILLER_42_209 VGND VGND VPWR VPWR sky130_fd_sc_hd__decap_3
XFILLER_70_529 VGND VGND VPWR VPWR sky130_fd_sc_hd__decap_3
XTAP_TAPCELL_ROW_18_470 VGND VPWR sky130_fd_sc_hd__tapvpwrvgnd_1
XFILLER_50_220 VGND VGND VPWR VPWR sky130_fd_sc_hd__decap_3
X_6825_ _6972_/CLK _6825_/D VGND VGND VPWR VPWR _6825_/Q sky130_fd_sc_hd__dfxtp_2
XFILLER_23_489 VGND VGND VPWR VPWR sky130_fd_sc_hd__decap_3
XFILLER_50_253 VGND VGND VPWR VPWR sky130_fd_sc_hd__fill_2
X_6756_ _6909_/CLK _6756_/D VGND VGND VPWR VPWR _6756_/Q sky130_fd_sc_hd__dfxtp_2
X_3968_ _7356_/Q _4510_/A0 _3968_/S VGND VGND VPWR VPWR _7356_/D sky130_fd_sc_hd__mux2_2
XFILLER_50_297 VGND VGND VPWR VPWR sky130_fd_sc_hd__decap_3
XFILLER_109_517 VGND VGND VPWR VPWR sky130_fd_sc_hd__decap_3
XFILLER_12_24 VGND VGND VPWR VPWR sky130_fd_sc_hd__decap_3
XFILLER_12_35 VGND VGND VPWR VPWR sky130_fd_sc_hd__decap_3
X_6687_ _7383_/CLK _6687_/D VGND VGND VPWR VPWR _6687_/Q sky130_fd_sc_hd__dfxtp_2
X_3899_ _6693_/Q _3925_/A2 _3925_/B1 _6871_/Q _3746_/C VGND VGND VPWR VPWR _3899_/X
+ sky130_fd_sc_hd__a221o_2
XFILLER_12_68 VGND VGND VPWR VPWR sky130_fd_sc_hd__fill_2
X_5569_ _7048_/Q _5647_/A _4910_/B VGND VGND VPWR VPWR _7048_/D sky130_fd_sc_hd__a21bo_2
XFILLER_104_200 VGND VGND VPWR VPWR sky130_fd_sc_hd__fill_2
XFILLER_104_222 VGND VGND VPWR VPWR sky130_fd_sc_hd__decap_3
XFILLER_88_39 VGND VGND VPWR VPWR sky130_fd_sc_hd__decap_3
X_7308_ _7340_/CLK _7308_/D _6588_/Y VGND VGND VPWR VPWR _7308_/Q sky130_fd_sc_hd__dfrtp_2
XFILLER_78_607 VGND VGND VPWR VPWR sky130_fd_sc_hd__decap_3
X_7239_ _7371_/CLK _7239_/D _6519_/Y VGND VGND VPWR VPWR _7239_/Q sky130_fd_sc_hd__dfrtp_2
XFILLER_104_299 VGND VGND VPWR VPWR sky130_fd_sc_hd__decap_3
XFILLER_86_651 VGND VGND VPWR VPWR sky130_fd_sc_hd__decap_3
XFILLER_18_206 VGND VGND VPWR VPWR sky130_fd_sc_hd__decap_3
XFILLER_37_21 VGND VGND VPWR VPWR sky130_fd_sc_hd__decap_3
XFILLER_73_301 VGND VGND VPWR VPWR sky130_fd_sc_hd__decap_3
XFILLER_86_684 VGND VGND VPWR VPWR sky130_fd_sc_hd__decap_3
XFILLER_92_109 VGND VGND VPWR VPWR sky130_fd_sc_hd__decap_3
XFILLER_100_483 VGND VGND VPWR VPWR sky130_fd_sc_hd__decap_3
XFILLER_37_43 VGND VGND VPWR VPWR sky130_fd_sc_hd__decap_3
XFILLER_46_548 VGND VGND VPWR VPWR sky130_fd_sc_hd__decap_3
XFILLER_85_172 VGND VGND VPWR VPWR sky130_fd_sc_hd__fill_2
XFILLER_85_194 VGND VGND VPWR VPWR sky130_fd_sc_hd__decap_3
XFILLER_26_272 VGND VGND VPWR VPWR sky130_fd_sc_hd__decap_3
XFILLER_73_389 VGND VGND VPWR VPWR sky130_fd_sc_hd__decap_3
XFILLER_53_42 VGND VGND VPWR VPWR sky130_fd_sc_hd__decap_3
XFILLER_54_592 VGND VGND VPWR VPWR sky130_fd_sc_hd__fill_2
XFILLER_41_253 VGND VGND VPWR VPWR sky130_fd_sc_hd__decap_3
XFILLER_53_75 VGND VGND VPWR VPWR sky130_fd_sc_hd__decap_3
XFILLER_5_143 VGND VGND VPWR VPWR sky130_fd_sc_hd__decap_3
XFILLER_108_572 VGND VGND VPWR VPWR sky130_fd_sc_hd__decap_3
XFILLER_5_187 VGND VGND VPWR VPWR sky130_fd_sc_hd__decap_3
XTAP_TAPCELL_ROW_114_1623 VGND VPWR sky130_fd_sc_hd__tapvpwrvgnd_1
XFILLER_78_94 VGND VGND VPWR VPWR sky130_fd_sc_hd__decap_3
XFILLER_96_415 VGND VGND VPWR VPWR sky130_fd_sc_hd__decap_3
XFILLER_1_393 VGND VGND VPWR VPWR sky130_fd_sc_hd__decap_3
XFILLER_68_139 VGND VGND VPWR VPWR sky130_fd_sc_hd__fill_1
XFILLER_49_364 VGND VGND VPWR VPWR sky130_fd_sc_hd__decap_3
XFILLER_76_150 VGND VGND VPWR VPWR sky130_fd_sc_hd__fill_2
XFILLER_76_161 VGND VGND VPWR VPWR sky130_fd_sc_hd__fill_1
XFILLER_77_673 VGND VGND VPWR VPWR sky130_fd_sc_hd__fill_2
XFILLER_92_610 VGND VGND VPWR VPWR sky130_fd_sc_hd__decap_3
XFILLER_94_71 VGND VGND VPWR VPWR sky130_fd_sc_hd__fill_2
XFILLER_24_209 VGND VGND VPWR VPWR sky130_fd_sc_hd__decap_3
XFILLER_37_559 VGND VGND VPWR VPWR sky130_fd_sc_hd__fill_1
XFILLER_52_507 VGND VGND VPWR VPWR sky130_fd_sc_hd__decap_3
XFILLER_91_131 VGND VGND VPWR VPWR sky130_fd_sc_hd__decap_3
XFILLER_91_186 VGND VGND VPWR VPWR sky130_fd_sc_hd__decap_3
X_4940_ _3522_/Y _4937_/Y _4939_/X VGND VGND VPWR VPWR _4940_/Y sky130_fd_sc_hd__o21ai_2
XFILLER_17_294 VGND VGND VPWR VPWR sky130_fd_sc_hd__decap_3
XFILLER_32_231 VGND VGND VPWR VPWR sky130_fd_sc_hd__fill_2
X_4871_ _4845_/A _4643_/Y _4841_/Y _4948_/A VGND VGND VPWR VPWR _4871_/Y sky130_fd_sc_hd__a31oi_2
XFILLER_20_415 VGND VGND VPWR VPWR sky130_fd_sc_hd__decap_3
XFILLER_32_264 VGND VGND VPWR VPWR sky130_fd_sc_hd__decap_3
XFILLER_60_584 VGND VGND VPWR VPWR sky130_fd_sc_hd__decap_3
X_6610_ _6610_/A VGND VGND VPWR VPWR _6610_/Y sky130_fd_sc_hd__inv_2
X_3822_ _3822_/A1 _4466_/A _5010_/C VGND VGND VPWR VPWR _7389_/D sky130_fd_sc_hd__a21o_2
XTAP_TAPCELL_ROW_43_771 VGND VPWR sky130_fd_sc_hd__tapvpwrvgnd_1
XFILLER_32_286 VGND VGND VPWR VPWR sky130_fd_sc_hd__decap_3
X_6541_ _6604_/A VGND VGND VPWR VPWR _6541_/Y sky130_fd_sc_hd__inv_2
X_3753_ _3629_/A _3752_/X _3753_/B1 VGND VGND VPWR VPWR _3753_/X sky130_fd_sc_hd__a21o_2
X_6472_ _6634_/A VGND VGND VPWR VPWR _6472_/Y sky130_fd_sc_hd__inv_2
X_3684_ _3684_/A1 _3753_/B1 _3683_/Y VGND VGND VPWR VPWR _7404_/D sky130_fd_sc_hd__a21bo_2
X_5423_ _5423_/A0 _5139_/X _5429_/S VGND VGND VPWR VPWR _7122_/D sky130_fd_sc_hd__mux2_2
X_5354_ _5354_/A0 _5139_/X _5360_/S VGND VGND VPWR VPWR _7154_/D sky130_fd_sc_hd__mux2_2
XFILLER_99_220 VGND VGND VPWR VPWR sky130_fd_sc_hd__decap_3
X_4305_ _7064_/Q _4305_/B VGND VGND VPWR VPWR _4364_/B sky130_fd_sc_hd__nor2_2
XFILLER_99_231 VGND VGND VPWR VPWR sky130_fd_sc_hd__decap_3
XFILLER_114_597 VGND VGND VPWR VPWR sky130_fd_sc_hd__fill_2
XFILLER_59_106 VGND VGND VPWR VPWR sky130_fd_sc_hd__decap_3
XFILLER_59_128 VGND VGND VPWR VPWR sky130_fd_sc_hd__decap_3
XFILLER_99_264 VGND VGND VPWR VPWR sky130_fd_sc_hd__decap_3
X_7024_ _7307_/CLK _7024_/D _6304_/Y VGND VGND VPWR VPWR _7024_/Q sky130_fd_sc_hd__dfrtp_2
X_4236_ _7163_/Q _4339_/B1 _4234_/X _4235_/X VGND VGND VPWR VPWR _4236_/X sky130_fd_sc_hd__a211o_2
XFILLER_114_37 VGND VGND VPWR VPWR sky130_fd_sc_hd__decap_3
XFILLER_67_150 VGND VGND VPWR VPWR sky130_fd_sc_hd__decap_3
XFILLER_68_651 VGND VGND VPWR VPWR sky130_fd_sc_hd__decap_3
XFILLER_74_109 VGND VGND VPWR VPWR sky130_fd_sc_hd__decap_3
X_4167_ _7393_/Q _4196_/A2 _4417_/A2 _7297_/Q _4166_/X VGND VGND VPWR VPWR _4167_/X
+ sky130_fd_sc_hd__a221o_2
XFILLER_114_59 VGND VGND VPWR VPWR sky130_fd_sc_hd__decap_3
XFILLER_67_172 VGND VGND VPWR VPWR sky130_fd_sc_hd__decap_3
XFILLER_67_183 VGND VGND VPWR VPWR sky130_fd_sc_hd__decap_3
XFILLER_83_643 VGND VGND VPWR VPWR sky130_fd_sc_hd__decap_3
XFILLER_95_470 VGND VGND VPWR VPWR sky130_fd_sc_hd__decap_3
XFILLER_82_131 VGND VGND VPWR VPWR sky130_fd_sc_hd__decap_3
XFILLER_82_153 VGND VGND VPWR VPWR sky130_fd_sc_hd__decap_3
XFILLER_83_676 VGND VGND VPWR VPWR sky130_fd_sc_hd__decap_3
X_4098_ _7333_/Q _3958_/S _4419_/B1 _7365_/Q _4188_/C1 VGND VGND VPWR VPWR _4098_/X
+ sky130_fd_sc_hd__a221o_2
XFILLER_70_326 VGND VGND VPWR VPWR sky130_fd_sc_hd__decap_3
XFILLER_82_186 VGND VGND VPWR VPWR sky130_fd_sc_hd__decap_3
XFILLER_23_231 VGND VGND VPWR VPWR sky130_fd_sc_hd__decap_3
XFILLER_36_592 VGND VGND VPWR VPWR sky130_fd_sc_hd__fill_1
XFILLER_70_359 VGND VGND VPWR VPWR sky130_fd_sc_hd__decap_3
XFILLER_82_197 VGND VGND VPWR VPWR sky130_fd_sc_hd__decap_3
XFILLER_23_12 VGND VGND VPWR VPWR sky130_fd_sc_hd__fill_1
XFILLER_90_29 VGND VGND VPWR VPWR sky130_fd_sc_hd__decap_3
X_6808_ _7198_/CLK _6808_/D VGND VGND VPWR VPWR _6808_/Q sky130_fd_sc_hd__dfxtp_2
XFILLER_23_275 VGND VGND VPWR VPWR sky130_fd_sc_hd__decap_3
XFILLER_51_595 VGND VGND VPWR VPWR sky130_fd_sc_hd__decap_3
XFILLER_23_78 VGND VGND VPWR VPWR sky130_fd_sc_hd__decap_3
X_6739_ _6967_/CLK _6739_/D VGND VGND VPWR VPWR _6739_/Q sky130_fd_sc_hd__dfxtp_2
XFILLER_109_325 VGND VGND VPWR VPWR sky130_fd_sc_hd__decap_3
XFILLER_99_38 VGND VGND VPWR VPWR sky130_fd_sc_hd__fill_1
XFILLER_109_358 VGND VGND VPWR VPWR sky130_fd_sc_hd__decap_3
XTAP_TAPCELL_ROW_21_498 VGND VPWR sky130_fd_sc_hd__tapvpwrvgnd_1
XFILLER_99_49 VGND VGND VPWR VPWR sky130_fd_sc_hd__decap_3
XFILLER_105_520 VGND VGND VPWR VPWR sky130_fd_sc_hd__decap_3
XFILLER_3_625 VGND VGND VPWR VPWR sky130_fd_sc_hd__fill_1
XFILLER_105_564 VGND VGND VPWR VPWR sky130_fd_sc_hd__decap_3
XFILLER_105_575 VGND VGND VPWR VPWR sky130_fd_sc_hd__decap_3
XFILLER_78_437 VGND VGND VPWR VPWR sky130_fd_sc_hd__decap_3
XFILLER_58_150 VGND VGND VPWR VPWR sky130_fd_sc_hd__decap_3
XFILLER_59_673 VGND VGND VPWR VPWR sky130_fd_sc_hd__fill_1
XFILLER_46_312 VGND VGND VPWR VPWR sky130_fd_sc_hd__decap_3
XFILLER_58_183 VGND VGND VPWR VPWR sky130_fd_sc_hd__decap_3
XFILLER_74_610 VGND VGND VPWR VPWR sky130_fd_sc_hd__decap_3
XFILLER_86_492 VGND VGND VPWR VPWR sky130_fd_sc_hd__decap_3
XFILLER_0_38 VGND VGND VPWR VPWR sky130_fd_sc_hd__decap_3
XFILLER_46_345 VGND VGND VPWR VPWR sky130_fd_sc_hd__decap_3
XFILLER_73_142 VGND VGND VPWR VPWR sky130_fd_sc_hd__fill_2
XFILLER_104_92 VGND VGND VPWR VPWR sky130_fd_sc_hd__decap_3
XFILLER_27_570 VGND VGND VPWR VPWR sky130_fd_sc_hd__decap_3
XFILLER_46_389 VGND VGND VPWR VPWR sky130_fd_sc_hd__decap_3
XFILLER_73_164 VGND VGND VPWR VPWR sky130_fd_sc_hd__decap_3
XFILLER_73_175 VGND VGND VPWR VPWR sky130_fd_sc_hd__decap_3
XFILLER_14_231 VGND VGND VPWR VPWR sky130_fd_sc_hd__decap_3
XFILLER_61_337 VGND VGND VPWR VPWR sky130_fd_sc_hd__fill_1
XFILLER_64_96 VGND VGND VPWR VPWR sky130_fd_sc_hd__fill_1
XTAP_TAPCELL_ROW_64_1021 VGND VPWR sky130_fd_sc_hd__tapvpwrvgnd_1
XTAP_TAPCELL_ROW_29_598 VGND VPWR sky130_fd_sc_hd__tapvpwrvgnd_1
XFILLER_14_253 VGND VGND VPWR VPWR sky130_fd_sc_hd__decap_3
XFILLER_9_25 VGND VGND VPWR VPWR sky130_fd_sc_hd__decap_3
XFILLER_9_69 VGND VGND VPWR VPWR sky130_fd_sc_hd__decap_3
XFILLER_9_47 VGND VGND VPWR VPWR sky130_fd_sc_hd__decap_3
XFILLER_80_62 VGND VGND VPWR VPWR sky130_fd_sc_hd__decap_3
XTAP_TAPCELL_ROW_40_730 VGND VPWR sky130_fd_sc_hd__tapvpwrvgnd_1
Xhold909 _7057_/Q VGND VGND VPWR VPWR _7057_/D sky130_fd_sc_hd__dlygate4sd3_1
XFILLER_115_317 VGND VGND VPWR VPWR sky130_fd_sc_hd__decap_3
XFILLER_50_6 VGND VGND VPWR VPWR sky130_fd_sc_hd__decap_3
XFILLER_89_60 VGND VGND VPWR VPWR sky130_fd_sc_hd__decap_3
XFILLER_89_93 VGND VGND VPWR VPWR sky130_fd_sc_hd__decap_3
XTAP_TAPCELL_ROW_75_1150 VGND VPWR sky130_fd_sc_hd__tapvpwrvgnd_1
XFILLER_69_426 VGND VGND VPWR VPWR sky130_fd_sc_hd__decap_3
XFILLER_96_212 VGND VGND VPWR VPWR sky130_fd_sc_hd__decap_3
X_5070_ _5073_/A _5050_/X _5053_/Y VGND VGND VPWR VPWR _5075_/A sky130_fd_sc_hd__o21a_2
XFILLER_1_190 VGND VGND VPWR VPWR sky130_fd_sc_hd__decap_3
XFILLER_49_161 VGND VGND VPWR VPWR sky130_fd_sc_hd__decap_3
XFILLER_49_172 VGND VGND VPWR VPWR sky130_fd_sc_hd__decap_3
XFILLER_77_481 VGND VGND VPWR VPWR sky130_fd_sc_hd__decap_3
XFILLER_96_289 VGND VGND VPWR VPWR sky130_fd_sc_hd__decap_3
XTAP_TAPCELL_ROW_48_830 VGND VPWR sky130_fd_sc_hd__tapvpwrvgnd_1
XFILLER_37_334 VGND VGND VPWR VPWR sky130_fd_sc_hd__fill_2
XFILLER_37_367 VGND VGND VPWR VPWR sky130_fd_sc_hd__decap_3
XFILLER_64_120 VGND VGND VPWR VPWR sky130_fd_sc_hd__decap_3
XFILLER_65_643 VGND VGND VPWR VPWR sky130_fd_sc_hd__decap_3
XFILLER_37_389 VGND VGND VPWR VPWR sky130_fd_sc_hd__decap_3
XFILLER_52_315 VGND VGND VPWR VPWR sky130_fd_sc_hd__decap_3
XFILLER_80_635 VGND VGND VPWR VPWR sky130_fd_sc_hd__decap_3
XFILLER_92_473 VGND VGND VPWR VPWR sky130_fd_sc_hd__decap_3
XFILLER_92_495 VGND VGND VPWR VPWR sky130_fd_sc_hd__decap_3
XFILLER_52_348 VGND VGND VPWR VPWR sky130_fd_sc_hd__decap_3
XFILLER_64_197 VGND VGND VPWR VPWR sky130_fd_sc_hd__decap_3
X_4923_ _4920_/A _4922_/X _4969_/B VGND VGND VPWR VPWR _4923_/Y sky130_fd_sc_hd__o21ai_2
XFILLER_100_17 VGND VGND VPWR VPWR sky130_fd_sc_hd__decap_3
X_4854_ _4764_/B _4096_/A _4633_/A _5101_/A VGND VGND VPWR VPWR _4854_/X sky130_fd_sc_hd__o22a_2
XFILLER_20_256 VGND VGND VPWR VPWR sky130_fd_sc_hd__decap_3
X_4785_ _4785_/A _4811_/B VGND VGND VPWR VPWR _4795_/B sky130_fd_sc_hd__nand2_2
X_3805_ _6948_/Q _3826_/A2 _3912_/B1 _6960_/Q VGND VGND VPWR VPWR _3805_/X sky130_fd_sc_hd__a22o_2
X_6524_ _6647_/A VGND VGND VPWR VPWR _6524_/Y sky130_fd_sc_hd__inv_2
XFILLER_106_306 VGND VGND VPWR VPWR sky130_fd_sc_hd__fill_2
XFILLER_109_15 VGND VGND VPWR VPWR sky130_fd_sc_hd__fill_2
XFILLER_109_26 VGND VGND VPWR VPWR sky130_fd_sc_hd__decap_3
XFILLER_109_37 VGND VGND VPWR VPWR sky130_fd_sc_hd__decap_3
X_6455_ _6584_/A VGND VGND VPWR VPWR _6455_/Y sky130_fd_sc_hd__inv_2
X_6386_ _6547_/A VGND VGND VPWR VPWR _6386_/Y sky130_fd_sc_hd__inv_2
X_3598_ _3598_/A _3611_/B VGND VGND VPWR VPWR _4614_/B sky130_fd_sc_hd__nor2_2
XFILLER_87_212 VGND VGND VPWR VPWR sky130_fd_sc_hd__decap_3
XFILLER_114_394 VGND VGND VPWR VPWR sky130_fd_sc_hd__decap_3
X_5268_ _5268_/A0 _5027_/X _5274_/S VGND VGND VPWR VPWR _7196_/D sky130_fd_sc_hd__mux2_2
XFILLER_102_589 VGND VGND VPWR VPWR sky130_fd_sc_hd__decap_3
XFILLER_85_29 VGND VGND VPWR VPWR sky130_fd_sc_hd__decap_3
XFILLER_87_278 VGND VGND VPWR VPWR sky130_fd_sc_hd__fill_2
X_7007_ _7368_/CLK _7007_/D _6287_/Y VGND VGND VPWR VPWR _7007_/Q sky130_fd_sc_hd__dfrtp_2
X_4219_ _7292_/Q _4417_/A2 _4267_/B1 _7164_/Q _4218_/X VGND VGND VPWR VPWR _4219_/X
+ sky130_fd_sc_hd__a221o_2
XTAP_TAPCELL_ROW_89_1319 VGND VPWR sky130_fd_sc_hd__tapvpwrvgnd_1
XFILLER_18_23 VGND VGND VPWR VPWR sky130_fd_sc_hd__decap_3
XFILLER_28_312 VGND VGND VPWR VPWR sky130_fd_sc_hd__fill_2
XFILLER_28_356 VGND VGND VPWR VPWR sky130_fd_sc_hd__decap_3
XFILLER_55_120 VGND VGND VPWR VPWR sky130_fd_sc_hd__decap_3
XFILLER_18_78 VGND VGND VPWR VPWR sky130_fd_sc_hd__decap_3
XFILLER_28_378 VGND VGND VPWR VPWR sky130_fd_sc_hd__decap_3
XFILLER_55_175 VGND VGND VPWR VPWR sky130_fd_sc_hd__decap_3
XFILLER_71_635 VGND VGND VPWR VPWR sky130_fd_sc_hd__decap_3
XFILLER_83_462 VGND VGND VPWR VPWR sky130_fd_sc_hd__decap_3
XFILLER_43_337 VGND VGND VPWR VPWR sky130_fd_sc_hd__decap_3
XFILLER_55_186 VGND VGND VPWR VPWR sky130_fd_sc_hd__decap_3
XFILLER_70_134 VGND VGND VPWR VPWR sky130_fd_sc_hd__decap_3
XFILLER_70_178 VGND VGND VPWR VPWR sky130_fd_sc_hd__decap_3
XFILLER_71_679 VGND VGND VPWR VPWR sky130_fd_sc_hd__decap_3
XTAP_TAPCELL_ROW_26_568 VGND VPWR sky130_fd_sc_hd__tapvpwrvgnd_1
XFILLER_34_88 VGND VGND VPWR VPWR sky130_fd_sc_hd__fill_2
XTAP_TAPCELL_ROW_54_899 VGND VPWR sky130_fd_sc_hd__tapvpwrvgnd_1
XFILLER_11_234 VGND VGND VPWR VPWR sky130_fd_sc_hd__decap_3
XFILLER_7_205 VGND VGND VPWR VPWR sky130_fd_sc_hd__decap_3
XFILLER_11_267 VGND VGND VPWR VPWR sky130_fd_sc_hd__decap_3
XFILLER_50_32 VGND VGND VPWR VPWR sky130_fd_sc_hd__decap_3
XFILLER_50_43 VGND VGND VPWR VPWR sky130_fd_sc_hd__decap_3
XFILLER_50_76 VGND VGND VPWR VPWR sky130_fd_sc_hd__decap_3
XFILLER_109_188 VGND VGND VPWR VPWR sky130_fd_sc_hd__decap_3
XFILLER_59_30 VGND VGND VPWR VPWR sky130_fd_sc_hd__decap_3
XFILLER_59_52 VGND VGND VPWR VPWR sky130_fd_sc_hd__decap_3
XFILLER_59_63 VGND VGND VPWR VPWR sky130_fd_sc_hd__decap_3
XFILLER_78_212 VGND VGND VPWR VPWR sky130_fd_sc_hd__fill_1
XFILLER_78_234 VGND VGND VPWR VPWR sky130_fd_sc_hd__decap_3
XFILLER_38_109 VGND VGND VPWR VPWR sky130_fd_sc_hd__decap_3
XFILLER_59_96 VGND VGND VPWR VPWR sky130_fd_sc_hd__fill_2
XFILLER_66_407 VGND VGND VPWR VPWR sky130_fd_sc_hd__decap_3
XFILLER_78_256 VGND VGND VPWR VPWR sky130_fd_sc_hd__fill_1
XFILLER_78_278 VGND VGND VPWR VPWR sky130_fd_sc_hd__fill_1
XFILLER_115_80 VGND VGND VPWR VPWR sky130_fd_sc_hd__decap_3
XFILLER_15_9 VGND VGND VPWR VPWR sky130_fd_sc_hd__decap_3
XFILLER_19_323 VGND VGND VPWR VPWR sky130_fd_sc_hd__decap_3
XFILLER_59_492 VGND VGND VPWR VPWR sky130_fd_sc_hd__decap_3
XFILLER_75_40 VGND VGND VPWR VPWR sky130_fd_sc_hd__decap_3
XTAP_TAPCELL_ROW_70_1091 VGND VPWR sky130_fd_sc_hd__tapvpwrvgnd_1
XFILLER_74_440 VGND VGND VPWR VPWR sky130_fd_sc_hd__decap_3
XFILLER_93_259 VGND VGND VPWR VPWR sky130_fd_sc_hd__decap_3
XTAP_TAPCELL_ROW_109_1555 VGND VPWR sky130_fd_sc_hd__tapvpwrvgnd_1
XFILLER_34_304 VGND VGND VPWR VPWR sky130_fd_sc_hd__decap_3
XFILLER_34_315 VGND VGND VPWR VPWR sky130_fd_sc_hd__fill_2
XFILLER_46_153 VGND VGND VPWR VPWR sky130_fd_sc_hd__decap_3
XFILLER_74_473 VGND VGND VPWR VPWR sky130_fd_sc_hd__decap_3
XFILLER_34_326 VGND VGND VPWR VPWR sky130_fd_sc_hd__fill_2
XFILLER_34_348 VGND VGND VPWR VPWR sky130_fd_sc_hd__decap_3
XFILLER_46_197 VGND VGND VPWR VPWR sky130_fd_sc_hd__decap_3
XFILLER_15_551 VGND VGND VPWR VPWR sky130_fd_sc_hd__fill_1
XFILLER_61_178 VGND VGND VPWR VPWR sky130_fd_sc_hd__decap_3
XFILLER_91_72 VGND VGND VPWR VPWR sky130_fd_sc_hd__decap_3
XFILLER_98_6 VGND VGND VPWR VPWR sky130_fd_sc_hd__fill_2
X_3521_ _3525_/A _3525_/B VGND VGND VPWR VPWR _3618_/C sky130_fd_sc_hd__nand2_2
XFILLER_116_615 VGND VGND VPWR VPWR sky130_fd_sc_hd__fill_1
XFILLER_116_626 VGND VGND VPWR VPWR sky130_fd_sc_hd__decap_3
Xhold706 _6756_/Q VGND VGND VPWR VPWR _6756_/D sky130_fd_sc_hd__dlygate4sd3_1
Xhold717 _6775_/Q VGND VGND VPWR VPWR _6775_/D sky130_fd_sc_hd__dlygate4sd3_1
Xhold728 _6773_/Q VGND VGND VPWR VPWR _6773_/D sky130_fd_sc_hd__dlygate4sd3_1
Xhold739 _6795_/Q VGND VGND VPWR VPWR _6795_/D sky130_fd_sc_hd__dlygate4sd3_1
X_3383_ _5118_/D _3383_/B VGND VGND VPWR VPWR _3383_/Y sky130_fd_sc_hd__nor2_2
XFILLER_69_234 VGND VGND VPWR VPWR sky130_fd_sc_hd__decap_3
XFILLER_97_532 VGND VGND VPWR VPWR sky130_fd_sc_hd__decap_3
X_5122_ _5122_/A0 _5121_/X _5136_/S VGND VGND VPWR VPWR _7254_/D sky130_fd_sc_hd__mux2_2
XFILLER_69_267 VGND VGND VPWR VPWR sky130_fd_sc_hd__decap_3
XFILLER_84_237 VGND VGND VPWR VPWR sky130_fd_sc_hd__decap_3
X_5053_ _5073_/A _5050_/X _5020_/A VGND VGND VPWR VPWR _5053_/Y sky130_fd_sc_hd__a21oi_2
XFILLER_37_131 VGND VGND VPWR VPWR sky130_fd_sc_hd__decap_3
XFILLER_37_164 VGND VGND VPWR VPWR sky130_fd_sc_hd__decap_3
XFILLER_37_175 VGND VGND VPWR VPWR sky130_fd_sc_hd__decap_3
XFILLER_65_473 VGND VGND VPWR VPWR sky130_fd_sc_hd__decap_3
XFILLER_92_270 VGND VGND VPWR VPWR sky130_fd_sc_hd__fill_1
XFILLER_111_16 VGND VGND VPWR VPWR sky130_fd_sc_hd__fill_1
XFILLER_25_326 VGND VGND VPWR VPWR sky130_fd_sc_hd__decap_3
XFILLER_25_337 VGND VGND VPWR VPWR sky130_fd_sc_hd__decap_3
XFILLER_52_134 VGND VGND VPWR VPWR sky130_fd_sc_hd__decap_3
XFILLER_65_495 VGND VGND VPWR VPWR sky130_fd_sc_hd__fill_1
XFILLER_80_421 VGND VGND VPWR VPWR sky130_fd_sc_hd__decap_3
XFILLER_111_49 VGND VGND VPWR VPWR sky130_fd_sc_hd__decap_3
XFILLER_52_156 VGND VGND VPWR VPWR sky130_fd_sc_hd__decap_3
XFILLER_80_465 VGND VGND VPWR VPWR sky130_fd_sc_hd__decap_3
XFILLER_40_318 VGND VGND VPWR VPWR sky130_fd_sc_hd__decap_3
XFILLER_80_498 VGND VGND VPWR VPWR sky130_fd_sc_hd__decap_3
X_4906_ _4814_/A _4886_/C _4904_/X _4905_/X VGND VGND VPWR VPWR _4906_/X sky130_fd_sc_hd__o31a_2
XTAP_TAPCELL_ROW_23_527 VGND VPWR sky130_fd_sc_hd__tapvpwrvgnd_1
X_4837_ hold995/X _4836_/X _4879_/S VGND VGND VPWR VPWR _7271_/D sky130_fd_sc_hd__mux2_2
XTAP_TAPCELL_ROW_51_869 VGND VPWR sky130_fd_sc_hd__tapvpwrvgnd_1
XTAP_TAPCELL_ROW_51_858 VGND VPWR sky130_fd_sc_hd__tapvpwrvgnd_1
X_4768_ _4762_/Y _4763_/X _4767_/X VGND VGND VPWR VPWR _4768_/Y sky130_fd_sc_hd__o21ai_2
X_6507_ _6532_/A VGND VGND VPWR VPWR _6507_/Y sky130_fd_sc_hd__inv_2
X_4699_ _6986_/Q _6987_/Q _5098_/A VGND VGND VPWR VPWR _5066_/A sky130_fd_sc_hd__and3_2
XFILLER_107_659 VGND VGND VPWR VPWR sky130_fd_sc_hd__fill_2
XFILLER_20_35 VGND VGND VPWR VPWR sky130_fd_sc_hd__decap_3
XFILLER_20_68 VGND VGND VPWR VPWR sky130_fd_sc_hd__decap_3
X_6438_ _6532_/A VGND VGND VPWR VPWR _6438_/Y sky130_fd_sc_hd__inv_2
XFILLER_106_158 VGND VGND VPWR VPWR sky130_fd_sc_hd__decap_3
XFILLER_115_670 VGND VGND VPWR VPWR sky130_fd_sc_hd__fill_2
XFILLER_20_79 VGND VGND VPWR VPWR sky130_fd_sc_hd__decap_3
XFILLER_88_510 VGND VGND VPWR VPWR sky130_fd_sc_hd__decap_3
XFILLER_96_17 VGND VGND VPWR VPWR sky130_fd_sc_hd__decap_3
XTAP_TAPCELL_ROW_95_1389 VGND VPWR sky130_fd_sc_hd__tapvpwrvgnd_1
XFILLER_29_11 VGND VGND VPWR VPWR sky130_fd_sc_hd__decap_3
X_6369_ _6532_/A VGND VGND VPWR VPWR _6369_/Y sky130_fd_sc_hd__inv_2
XFILLER_102_342 VGND VGND VPWR VPWR sky130_fd_sc_hd__decap_3
XFILLER_29_44 VGND VGND VPWR VPWR sky130_fd_sc_hd__decap_3
XFILLER_29_66 VGND VGND VPWR VPWR sky130_fd_sc_hd__decap_3
XFILLER_75_237 VGND VGND VPWR VPWR sky130_fd_sc_hd__decap_3
XFILLER_88_587 VGND VGND VPWR VPWR sky130_fd_sc_hd__fill_1
XFILLER_88_598 VGND VGND VPWR VPWR sky130_fd_sc_hd__fill_1
XFILLER_28_131 VGND VGND VPWR VPWR sky130_fd_sc_hd__decap_3
XFILLER_29_99 VGND VGND VPWR VPWR sky130_fd_sc_hd__decap_3
XFILLER_56_440 VGND VGND VPWR VPWR sky130_fd_sc_hd__decap_3
XTAP_TAPCELL_ROW_59_958 VGND VPWR sky130_fd_sc_hd__tapvpwrvgnd_1
XFILLER_16_304 VGND VGND VPWR VPWR sky130_fd_sc_hd__decap_3
XFILLER_28_153 VGND VGND VPWR VPWR sky130_fd_sc_hd__decap_3
XFILLER_90_207 VGND VGND VPWR VPWR sky130_fd_sc_hd__decap_3
XTAP_TAPCELL_ROW_3_285 VGND VPWR sky130_fd_sc_hd__tapvpwrvgnd_1
XFILLER_16_348 VGND VGND VPWR VPWR sky130_fd_sc_hd__decap_3
XFILLER_28_186 VGND VGND VPWR VPWR sky130_fd_sc_hd__decap_3
XFILLER_28_197 VGND VGND VPWR VPWR sky130_fd_sc_hd__decap_3
XFILLER_56_495 VGND VGND VPWR VPWR sky130_fd_sc_hd__decap_3
XFILLER_83_281 VGND VGND VPWR VPWR sky130_fd_sc_hd__decap_3
XFILLER_45_76 VGND VGND VPWR VPWR sky130_fd_sc_hd__decap_3
XFILLER_101_60 VGND VGND VPWR VPWR sky130_fd_sc_hd__decap_3
XFILLER_43_178 VGND VGND VPWR VPWR sky130_fd_sc_hd__decap_3
XFILLER_71_487 VGND VGND VPWR VPWR sky130_fd_sc_hd__decap_3
XFILLER_61_42 VGND VGND VPWR VPWR sky130_fd_sc_hd__fill_1
XTAP_TAPCELL_ROW_104_1496 VGND VPWR sky130_fd_sc_hd__tapvpwrvgnd_1
XFILLER_61_53 VGND VGND VPWR VPWR sky130_fd_sc_hd__decap_3
XFILLER_61_75 VGND VGND VPWR VPWR sky130_fd_sc_hd__decap_3
XANTENNA_8 _4059_/X VGND VGND VPWR VPWR sky130_fd_sc_hd__diode_2
XFILLER_113_607 VGND VGND VPWR VPWR sky130_fd_sc_hd__decap_3
XFILLER_98_329 VGND VGND VPWR VPWR sky130_fd_sc_hd__decap_3
XFILLER_98_318 VGND VGND VPWR VPWR sky130_fd_sc_hd__decap_3
XFILLER_3_296 VGND VGND VPWR VPWR sky130_fd_sc_hd__decap_3
XTAP_TAPCELL_ROW_72_1120 VGND VPWR sky130_fd_sc_hd__tapvpwrvgnd_1
XFILLER_66_215 VGND VGND VPWR VPWR sky130_fd_sc_hd__decap_3
XFILLER_86_50 VGND VGND VPWR VPWR sky130_fd_sc_hd__decap_3
XFILLER_86_83 VGND VGND VPWR VPWR sky130_fd_sc_hd__fill_1
XFILLER_94_524 VGND VGND VPWR VPWR sky130_fd_sc_hd__decap_3
XFILLER_47_440 VGND VGND VPWR VPWR sky130_fd_sc_hd__decap_3
XFILLER_66_248 VGND VGND VPWR VPWR sky130_fd_sc_hd__decap_3
XFILLER_66_259 VGND VGND VPWR VPWR sky130_fd_sc_hd__decap_3
XFILLER_86_94 VGND VGND VPWR VPWR sky130_fd_sc_hd__decap_3
XFILLER_94_568 VGND VGND VPWR VPWR sky130_fd_sc_hd__decap_3
XFILLER_19_164 VGND VGND VPWR VPWR sky130_fd_sc_hd__decap_3
XFILLER_35_613 VGND VGND VPWR VPWR sky130_fd_sc_hd__decap_3
XFILLER_19_175 VGND VGND VPWR VPWR sky130_fd_sc_hd__decap_3
XFILLER_19_197 VGND VGND VPWR VPWR sky130_fd_sc_hd__decap_3
XFILLER_34_123 VGND VGND VPWR VPWR sky130_fd_sc_hd__decap_3
XFILLER_62_421 VGND VGND VPWR VPWR sky130_fd_sc_hd__decap_3
XFILLER_34_167 VGND VGND VPWR VPWR sky130_fd_sc_hd__decap_3
XFILLER_62_454 VGND VGND VPWR VPWR sky130_fd_sc_hd__decap_3
XFILLER_30_362 VGND VGND VPWR VPWR sky130_fd_sc_hd__fill_2
X_5671_ _5671_/A _5671_/B VGND VGND VPWR VPWR _6983_/D sky130_fd_sc_hd__and2_2
XFILLER_30_395 VGND VGND VPWR VPWR sky130_fd_sc_hd__decap_3
X_4622_ _5072_/B _4621_/X _5071_/B VGND VGND VPWR VPWR _4622_/X sky130_fd_sc_hd__a21bo_2
X_7341_ _7403_/CLK _7341_/D _6621_/Y VGND VGND VPWR VPWR _7341_/Q sky130_fd_sc_hd__dfrtp_2
X_7272_ _7365_/CLK _7272_/D _6552_/Y VGND VGND VPWR VPWR _7272_/Q sky130_fd_sc_hd__dfrtp_2
X_4484_ _4484_/A0 _4550_/A _4488_/S VGND VGND VPWR VPWR _7337_/D sky130_fd_sc_hd__mux2_2
X_3504_ _3501_/X _3502_/X _3630_/A VGND VGND VPWR VPWR _3505_/B sky130_fd_sc_hd__a21oi_2
XFILLER_116_467 VGND VGND VPWR VPWR sky130_fd_sc_hd__fill_1
XFILLER_112_651 VGND VGND VPWR VPWR sky130_fd_sc_hd__decap_3
XFILLER_97_340 VGND VGND VPWR VPWR sky130_fd_sc_hd__decap_3
X_3366_ _3376_/A _3376_/B _3399_/B _5118_/A VGND VGND VPWR VPWR _3366_/X sky130_fd_sc_hd__o211a_2
XFILLER_97_373 VGND VGND VPWR VPWR sky130_fd_sc_hd__decap_3
Xhold1203 _7141_/Q VGND VGND VPWR VPWR _5383_/A0 sky130_fd_sc_hd__dlygate4sd3_1
X_5105_ _4467_/B _3874_/X _5104_/Y _5666_/A VGND VGND VPWR VPWR _5105_/X sky130_fd_sc_hd__a31o_2
XFILLER_38_440 VGND VGND VPWR VPWR sky130_fd_sc_hd__decap_3
XFILLER_57_237 VGND VGND VPWR VPWR sky130_fd_sc_hd__decap_3
XFILLER_85_546 VGND VGND VPWR VPWR sky130_fd_sc_hd__decap_3
XFILLER_85_557 VGND VGND VPWR VPWR sky130_fd_sc_hd__decap_3
XFILLER_85_568 VGND VGND VPWR VPWR sky130_fd_sc_hd__decap_3
X_5036_ _5036_/A _4674_/X VGND VGND VPWR VPWR _5038_/A sky130_fd_sc_hd__or2b_2
XFILLER_38_473 VGND VGND VPWR VPWR sky130_fd_sc_hd__decap_3
XTAP_TAPCELL_ROW_56_928 VGND VPWR sky130_fd_sc_hd__tapvpwrvgnd_1
XFILLER_53_432 VGND VGND VPWR VPWR sky130_fd_sc_hd__decap_3
XFILLER_65_281 VGND VGND VPWR VPWR sky130_fd_sc_hd__decap_3
XTAP_TAPCELL_ROW_0_244 VGND VPWR sky130_fd_sc_hd__tapvpwrvgnd_1
XFILLER_25_134 VGND VGND VPWR VPWR sky130_fd_sc_hd__decap_3
XFILLER_41_605 VGND VGND VPWR VPWR sky130_fd_sc_hd__fill_1
XFILLER_80_240 VGND VGND VPWR VPWR sky130_fd_sc_hd__decap_3
X_6987_ _7396_/CLK _6987_/D _6267_/Y VGND VGND VPWR VPWR _6987_/Q sky130_fd_sc_hd__dfrtp_2
XTAP_TAPCELL_ROW_0_255 VGND VPWR sky130_fd_sc_hd__tapvpwrvgnd_1
XFILLER_13_329 VGND VGND VPWR VPWR sky130_fd_sc_hd__decap_3
XFILLER_15_24 VGND VGND VPWR VPWR sky130_fd_sc_hd__fill_2
XFILLER_15_57 VGND VGND VPWR VPWR sky130_fd_sc_hd__decap_3
XFILLER_25_178 VGND VGND VPWR VPWR sky130_fd_sc_hd__decap_3
XFILLER_53_487 VGND VGND VPWR VPWR sky130_fd_sc_hd__decap_3
XFILLER_80_262 VGND VGND VPWR VPWR sky130_fd_sc_hd__decap_3
XTAP_TAPCELL_ROW_36_685 VGND VPWR sky130_fd_sc_hd__tapvpwrvgnd_1
XFILLER_40_159 VGND VGND VPWR VPWR sky130_fd_sc_hd__decap_3
XFILLER_80_295 VGND VGND VPWR VPWR sky130_fd_sc_hd__decap_3
XFILLER_21_340 VGND VGND VPWR VPWR sky130_fd_sc_hd__decap_3
XFILLER_21_362 VGND VGND VPWR VPWR sky130_fd_sc_hd__decap_3
XFILLER_31_34 VGND VGND VPWR VPWR sky130_fd_sc_hd__decap_3
XTAP_TAPCELL_ROW_97_1418 VGND VPWR sky130_fd_sc_hd__tapvpwrvgnd_1
XFILLER_107_423 VGND VGND VPWR VPWR sky130_fd_sc_hd__decap_3
XFILLER_107_467 VGND VGND VPWR VPWR sky130_fd_sc_hd__decap_3
XFILLER_0_200 VGND VGND VPWR VPWR sky130_fd_sc_hd__decap_3
XTAP_TAPCELL_ROW_8_344 VGND VPWR sky130_fd_sc_hd__tapvpwrvgnd_1
XFILLER_0_222 VGND VGND VPWR VPWR sky130_fd_sc_hd__fill_2
XFILLER_0_266 VGND VGND VPWR VPWR sky130_fd_sc_hd__decap_3
XFILLER_102_161 VGND VGND VPWR VPWR sky130_fd_sc_hd__fill_1
XFILLER_103_673 VGND VGND VPWR VPWR sky130_fd_sc_hd__fill_1
XFILLER_48_226 VGND VGND VPWR VPWR sky130_fd_sc_hd__decap_3
XFILLER_76_513 VGND VGND VPWR VPWR sky130_fd_sc_hd__decap_3
XFILLER_88_362 VGND VGND VPWR VPWR sky130_fd_sc_hd__fill_2
XFILLER_102_183 VGND VGND VPWR VPWR sky130_fd_sc_hd__decap_3
XFILLER_48_259 VGND VGND VPWR VPWR sky130_fd_sc_hd__decap_3
XFILLER_29_473 VGND VGND VPWR VPWR sky130_fd_sc_hd__decap_3
XFILLER_56_53 VGND VGND VPWR VPWR sky130_fd_sc_hd__decap_3
XFILLER_44_421 VGND VGND VPWR VPWR sky130_fd_sc_hd__decap_3
XFILLER_56_292 VGND VGND VPWR VPWR sky130_fd_sc_hd__decap_3
XFILLER_63_229 VGND VGND VPWR VPWR sky130_fd_sc_hd__decap_3
XTAP_TAPCELL_ROW_106_1525 VGND VPWR sky130_fd_sc_hd__tapvpwrvgnd_1
XFILLER_16_134 VGND VGND VPWR VPWR sky130_fd_sc_hd__decap_3
XFILLER_16_156 VGND VGND VPWR VPWR sky130_fd_sc_hd__decap_3
XFILLER_44_465 VGND VGND VPWR VPWR sky130_fd_sc_hd__decap_3
XFILLER_71_240 VGND VGND VPWR VPWR sky130_fd_sc_hd__decap_3
XPHY_EDGE_ROW_113_Right_113 VGND VGND VPWR VPWR sky130_fd_sc_hd__decap_3
XFILLER_16_189 VGND VGND VPWR VPWR sky130_fd_sc_hd__decap_3
XFILLER_71_273 VGND VGND VPWR VPWR sky130_fd_sc_hd__decap_3
XFILLER_72_41 VGND VGND VPWR VPWR sky130_fd_sc_hd__decap_3
XFILLER_31_137 VGND VGND VPWR VPWR sky130_fd_sc_hd__decap_3
XFILLER_31_159 VGND VGND VPWR VPWR sky130_fd_sc_hd__decap_3
XFILLER_72_85 VGND VGND VPWR VPWR sky130_fd_sc_hd__decap_3
XFILLER_72_96 VGND VGND VPWR VPWR sky130_fd_sc_hd__fill_2
XFILLER_82_9 VGND VGND VPWR VPWR sky130_fd_sc_hd__decap_3
XFILLER_8_333 VGND VGND VPWR VPWR sky130_fd_sc_hd__decap_3
XFILLER_79_340 VGND VGND VPWR VPWR sky130_fd_sc_hd__fill_2
XFILLER_97_60 VGND VGND VPWR VPWR sky130_fd_sc_hd__decap_3
XFILLER_97_71 VGND VGND VPWR VPWR sky130_fd_sc_hd__decap_3
XFILLER_67_502 VGND VGND VPWR VPWR sky130_fd_sc_hd__fill_2
XFILLER_79_384 VGND VGND VPWR VPWR sky130_fd_sc_hd__decap_3
XFILLER_11_3 VGND VGND VPWR VPWR sky130_fd_sc_hd__decap_3
XFILLER_67_535 VGND VGND VPWR VPWR sky130_fd_sc_hd__decap_3
XFILLER_94_321 VGND VGND VPWR VPWR sky130_fd_sc_hd__decap_3
XFILLER_54_218 VGND VGND VPWR VPWR sky130_fd_sc_hd__decap_3
XFILLER_67_579 VGND VGND VPWR VPWR sky130_fd_sc_hd__decap_3
XFILLER_94_376 VGND VGND VPWR VPWR sky130_fd_sc_hd__decap_3
XFILLER_47_292 VGND VGND VPWR VPWR sky130_fd_sc_hd__fill_2
X_6910_ _6968_/CLK _6910_/D VGND VGND VPWR VPWR _6910_/Q sky130_fd_sc_hd__dfxtp_2
XFILLER_62_240 VGND VGND VPWR VPWR sky130_fd_sc_hd__decap_3
X_6841_ _6972_/CLK _6841_/D VGND VGND VPWR VPWR _6841_/Q sky130_fd_sc_hd__dfxtp_2
XFILLER_50_413 VGND VGND VPWR VPWR sky130_fd_sc_hd__decap_3
XFILLER_62_284 VGND VGND VPWR VPWR sky130_fd_sc_hd__decap_3
XFILLER_90_571 VGND VGND VPWR VPWR sky130_fd_sc_hd__decap_3
XTAP_TAPCELL_ROW_81_1219 VGND VPWR sky130_fd_sc_hd__tapvpwrvgnd_1
XFILLER_50_435 VGND VGND VPWR VPWR sky130_fd_sc_hd__decap_3
XFILLER_50_457 VGND VGND VPWR VPWR sky130_fd_sc_hd__decap_3
X_6772_ _6965_/CLK _6772_/D VGND VGND VPWR VPWR _6772_/Q sky130_fd_sc_hd__dfxtp_2
XTAP_TAPCELL_ROW_33_644 VGND VPWR sky130_fd_sc_hd__tapvpwrvgnd_1
XFILLER_22_159 VGND VGND VPWR VPWR sky130_fd_sc_hd__decap_3
X_5723_ _7367_/Q hold916/X _5737_/S VGND VGND VPWR VPWR _6711_/D sky130_fd_sc_hd__mux2_2
XTAP_TAPCELL_ROW_61_986 VGND VPWR sky130_fd_sc_hd__tapvpwrvgnd_1
X_5654_ _5665_/A VGND VGND VPWR VPWR _5654_/Y sky130_fd_sc_hd__inv_2
XFILLER_30_192 VGND VGND VPWR VPWR sky130_fd_sc_hd__decap_3
XFILLER_116_231 VGND VGND VPWR VPWR sky130_fd_sc_hd__decap_3
X_7324_ _7401_/CLK _7324_/D _6604_/Y VGND VGND VPWR VPWR _7324_/Q sky130_fd_sc_hd__dfrtp_2
X_5585_ hold950/X _5587_/B _5106_/X VGND VGND VPWR VPWR _7036_/D sky130_fd_sc_hd__a21o_2
XFILLER_116_253 VGND VGND VPWR VPWR sky130_fd_sc_hd__decap_3
X_4536_ hold946/X _3398_/Y _3488_/X VGND VGND VPWR VPWR _7311_/D sky130_fd_sc_hd__a21o_2
X_7255_ clkload9/A _7255_/D _6535_/Y VGND VGND VPWR VPWR _7255_/Q sky130_fd_sc_hd__dfrtp_2
X_4467_ _4467_/A _4467_/B VGND VGND VPWR VPWR _4664_/A sky130_fd_sc_hd__nor2_2
XTAP_TAPCELL_ROW_92_1359 VGND VPWR sky130_fd_sc_hd__tapvpwrvgnd_1
XFILLER_104_448 VGND VGND VPWR VPWR sky130_fd_sc_hd__decap_3
XFILLER_89_148 VGND VGND VPWR VPWR sky130_fd_sc_hd__decap_3
X_7186_ clkload3/A _7186_/D _6466_/Y VGND VGND VPWR VPWR _7186_/Q sky130_fd_sc_hd__dfrtp_2
X_4398_ _7338_/Q _3947_/S _4488_/S _7306_/Q VGND VGND VPWR VPWR _4398_/X sky130_fd_sc_hd__a22o_2
X_3418_ _7283_/Q _5136_/S _3417_/X _7091_/Q VGND VGND VPWR VPWR _3418_/X sky130_fd_sc_hd__a22o_2
XFILLER_100_610 VGND VGND VPWR VPWR sky130_fd_sc_hd__decap_3
XFILLER_85_310 VGND VGND VPWR VPWR sky130_fd_sc_hd__decap_3
Xhold1000 _7038_/Q VGND VGND VPWR VPWR _5581_/A0 sky130_fd_sc_hd__dlygate4sd3_1
X_3349_ _6982_/Q _5294_/A VGND VGND VPWR VPWR _3350_/B sky130_fd_sc_hd__nand2_2
XTAP_TAPCELL_ROW_5_314 VGND VPWR sky130_fd_sc_hd__tapvpwrvgnd_1
XFILLER_100_643 VGND VGND VPWR VPWR sky130_fd_sc_hd__fill_1
XFILLER_97_181 VGND VGND VPWR VPWR sky130_fd_sc_hd__fill_1
Xhold1011 _7276_/Q VGND VGND VPWR VPWR _4753_/A0 sky130_fd_sc_hd__dlygate4sd3_1
Xhold1022 _7185_/Q VGND VGND VPWR VPWR _5288_/A0 sky130_fd_sc_hd__dlygate4sd3_1
Xhold1033 _7274_/Q VGND VGND VPWR VPWR _4793_/A0 sky130_fd_sc_hd__dlygate4sd3_1
XFILLER_73_505 VGND VGND VPWR VPWR sky130_fd_sc_hd__decap_3
XFILLER_93_18 VGND VGND VPWR VPWR sky130_fd_sc_hd__decap_3
Xhold1044 _7209_/Q VGND VGND VPWR VPWR _5241_/A0 sky130_fd_sc_hd__dlygate4sd3_1
Xhold1055 _7197_/Q VGND VGND VPWR VPWR _5266_/A0 sky130_fd_sc_hd__dlygate4sd3_1
Xhold1066 _7217_/Q VGND VGND VPWR VPWR _5223_/A sky130_fd_sc_hd__dlygate4sd3_1
XFILLER_26_12 VGND VGND VPWR VPWR sky130_fd_sc_hd__decap_3
XFILLER_26_410 VGND VGND VPWR VPWR sky130_fd_sc_hd__decap_3
XFILLER_26_421 VGND VGND VPWR VPWR sky130_fd_sc_hd__fill_1
XFILLER_73_538 VGND VGND VPWR VPWR sky130_fd_sc_hd__decap_3
Xhold1077 _7321_/Q VGND VGND VPWR VPWR _4517_/A0 sky130_fd_sc_hd__dlygate4sd3_1
Xhold1088 _7334_/Q VGND VGND VPWR VPWR _4491_/A0 sky130_fd_sc_hd__dlygate4sd3_1
Xhold1099 _7049_/Q VGND VGND VPWR VPWR _5568_/A1 sky130_fd_sc_hd__dlygate4sd3_1
X_5019_ _4243_/Y _5032_/B _4989_/X _5018_/Y VGND VGND VPWR VPWR _5020_/B sky130_fd_sc_hd__a22o_2
XFILLER_13_104 VGND VGND VPWR VPWR sky130_fd_sc_hd__decap_3
XFILLER_26_67 VGND VGND VPWR VPWR sky130_fd_sc_hd__decap_3
XFILLER_41_413 VGND VGND VPWR VPWR sky130_fd_sc_hd__decap_3
XFILLER_53_262 VGND VGND VPWR VPWR sky130_fd_sc_hd__decap_3
XFILLER_53_284 VGND VGND VPWR VPWR sky130_fd_sc_hd__decap_3
XFILLER_13_137 VGND VGND VPWR VPWR sky130_fd_sc_hd__decap_3
XFILLER_41_457 VGND VGND VPWR VPWR sky130_fd_sc_hd__decap_3
XTAP_TAPCELL_ROW_101_1466 VGND VPWR sky130_fd_sc_hd__tapvpwrvgnd_1
XFILLER_9_119 VGND VGND VPWR VPWR sky130_fd_sc_hd__decap_3
XFILLER_21_181 VGND VGND VPWR VPWR sky130_fd_sc_hd__decap_3
XFILLER_42_88 VGND VGND VPWR VPWR sky130_fd_sc_hd__decap_3
XFILLER_107_220 VGND VGND VPWR VPWR sky130_fd_sc_hd__decap_3
XFILLER_5_314 VGND VGND VPWR VPWR sky130_fd_sc_hd__decap_3
XFILLER_107_231 VGND VGND VPWR VPWR sky130_fd_sc_hd__decap_3
XFILLER_5_358 VGND VGND VPWR VPWR sky130_fd_sc_hd__decap_3
XFILLER_107_275 VGND VGND VPWR VPWR sky130_fd_sc_hd__decap_3
XFILLER_3_27 VGND VGND VPWR VPWR sky130_fd_sc_hd__decap_3
XFILLER_3_38 VGND VGND VPWR VPWR sky130_fd_sc_hd__decap_3
XFILLER_96_619 VGND VGND VPWR VPWR sky130_fd_sc_hd__decap_3
XFILLER_110_407 VGND VGND VPWR VPWR sky130_fd_sc_hd__decap_3
XFILLER_49_524 VGND VGND VPWR VPWR sky130_fd_sc_hd__fill_2
XFILLER_67_41 VGND VGND VPWR VPWR sky130_fd_sc_hd__decap_3
XFILLER_89_671 VGND VGND VPWR VPWR sky130_fd_sc_hd__fill_1
XFILLER_89_682 VGND VGND VPWR VPWR sky130_fd_sc_hd__decap_3
XFILLER_95_107 VGND VGND VPWR VPWR sky130_fd_sc_hd__decap_3
XFILLER_95_118 VGND VGND VPWR VPWR sky130_fd_sc_hd__decap_3
XTAP_TAPCELL_ROW_112_1595 VGND VPWR sky130_fd_sc_hd__tapvpwrvgnd_1
XFILLER_49_557 VGND VGND VPWR VPWR sky130_fd_sc_hd__decap_3
XFILLER_64_516 VGND VGND VPWR VPWR sky130_fd_sc_hd__decap_3
XFILLER_67_96 VGND VGND VPWR VPWR sky130_fd_sc_hd__decap_3
XFILLER_76_365 VGND VGND VPWR VPWR sky130_fd_sc_hd__decap_3
XFILLER_17_410 VGND VGND VPWR VPWR sky130_fd_sc_hd__fill_2
XFILLER_76_398 VGND VGND VPWR VPWR sky130_fd_sc_hd__decap_3
XFILLER_91_335 VGND VGND VPWR VPWR sky130_fd_sc_hd__fill_1
XFILLER_17_443 VGND VGND VPWR VPWR sky130_fd_sc_hd__decap_3
XFILLER_91_346 VGND VGND VPWR VPWR sky130_fd_sc_hd__fill_1
XFILLER_91_379 VGND VGND VPWR VPWR sky130_fd_sc_hd__decap_3
XTAP_TAPCELL_ROW_67_1052 VGND VPWR sky130_fd_sc_hd__tapvpwrvgnd_1
XFILLER_32_424 VGND VGND VPWR VPWR sky130_fd_sc_hd__fill_1
XFILLER_44_262 VGND VGND VPWR VPWR sky130_fd_sc_hd__decap_3
XFILLER_83_95 VGND VGND VPWR VPWR sky130_fd_sc_hd__decap_3
XFILLER_32_446 VGND VGND VPWR VPWR sky130_fd_sc_hd__fill_2
XFILLER_80_6 VGND VGND VPWR VPWR sky130_fd_sc_hd__decap_3
XTAP_TAPCELL_ROW_30_614 VGND VPWR sky130_fd_sc_hd__tapvpwrvgnd_1
XFILLER_12_192 VGND VGND VPWR VPWR sky130_fd_sc_hd__decap_3
XFILLER_8_141 VGND VGND VPWR VPWR sky130_fd_sc_hd__decap_3
XFILLER_8_174 VGND VGND VPWR VPWR sky130_fd_sc_hd__decap_3
XFILLER_59_3 VGND VGND VPWR VPWR sky130_fd_sc_hd__decap_3
XTAP_TAPCELL_ROW_10_371 VGND VPWR sky130_fd_sc_hd__tapvpwrvgnd_1
XFILLER_113_201 VGND VGND VPWR VPWR sky130_fd_sc_hd__decap_3
X_4321_ _7098_/Q _4351_/A2 _4351_/B1 _7130_/Q VGND VGND VPWR VPWR _4321_/X sky130_fd_sc_hd__a22o_2
XTAP_TAPCELL_ROW_78_1192 VGND VPWR sky130_fd_sc_hd__tapvpwrvgnd_1
XFILLER_99_435 VGND VGND VPWR VPWR sky130_fd_sc_hd__decap_3
XFILLER_4_380 VGND VGND VPWR VPWR sky130_fd_sc_hd__fill_2
XFILLER_4_391 VGND VGND VPWR VPWR sky130_fd_sc_hd__decap_3
X_7040_ _7381_/CLK _7040_/D _6320_/Y VGND VGND VPWR VPWR _7040_/Q sky130_fd_sc_hd__dfrtp_2
X_4252_ _7197_/Q _4471_/S _4270_/B _7357_/Q VGND VGND VPWR VPWR _4252_/X sky130_fd_sc_hd__a22o_2
XFILLER_99_479 VGND VGND VPWR VPWR sky130_fd_sc_hd__decap_3
XFILLER_101_418 VGND VGND VPWR VPWR sky130_fd_sc_hd__decap_3
XFILLER_86_118 VGND VGND VPWR VPWR sky130_fd_sc_hd__decap_3
XFILLER_67_343 VGND VGND VPWR VPWR sky130_fd_sc_hd__decap_3
X_4183_ _7360_/Q _4270_/B _4267_/B1 _7168_/Q _4182_/X VGND VGND VPWR VPWR _4183_/X
+ sky130_fd_sc_hd__a221o_2
XTAP_TAPCELL_ROW_38_703 VGND VPWR sky130_fd_sc_hd__tapvpwrvgnd_1
XFILLER_27_218 VGND VGND VPWR VPWR sky130_fd_sc_hd__decap_3
XFILLER_55_549 VGND VGND VPWR VPWR sky130_fd_sc_hd__decap_3
XFILLER_94_195 VGND VGND VPWR VPWR sky130_fd_sc_hd__fill_1
XFILLER_70_508 VGND VGND VPWR VPWR sky130_fd_sc_hd__decap_3
XFILLER_82_346 VGND VGND VPWR VPWR sky130_fd_sc_hd__decap_3
XFILLER_23_402 VGND VGND VPWR VPWR sky130_fd_sc_hd__decap_3
XFILLER_35_251 VGND VGND VPWR VPWR sky130_fd_sc_hd__decap_3
XFILLER_35_273 VGND VGND VPWR VPWR sky130_fd_sc_hd__decap_3
XFILLER_82_379 VGND VGND VPWR VPWR sky130_fd_sc_hd__decap_3
XFILLER_35_284 VGND VGND VPWR VPWR sky130_fd_sc_hd__decap_3
XFILLER_50_232 VGND VGND VPWR VPWR sky130_fd_sc_hd__decap_3
XFILLER_63_593 VGND VGND VPWR VPWR sky130_fd_sc_hd__decap_3
XFILLER_90_390 VGND VGND VPWR VPWR sky130_fd_sc_hd__decap_3
X_6824_ _6968_/CLK _6824_/D VGND VGND VPWR VPWR _6824_/Q sky130_fd_sc_hd__dfxtp_2
XTAP_TAPCELL_ROW_18_471 VGND VPWR sky130_fd_sc_hd__tapvpwrvgnd_1
XFILLER_23_468 VGND VGND VPWR VPWR sky130_fd_sc_hd__fill_1
XFILLER_50_276 VGND VGND VPWR VPWR sky130_fd_sc_hd__decap_3
X_6755_ _7351_/CLK _6755_/D VGND VGND VPWR VPWR _6755_/Q sky130_fd_sc_hd__dfxtp_2
X_5706_ _7359_/Q hold934/X _5706_/S VGND VGND VPWR VPWR _6703_/D sky130_fd_sc_hd__mux2_2
XFILLER_109_529 VGND VGND VPWR VPWR sky130_fd_sc_hd__decap_3
Xclkbuf_leaf_30_clk clkbuf_3_2__f_clk/X VGND VGND VPWR VPWR _6976_/CLK sky130_fd_sc_hd__clkbuf_16
X_6686_ _6686_/A VGND VGND VPWR VPWR _6686_/Y sky130_fd_sc_hd__inv_2
X_3898_ _6919_/Q _3926_/A2 _3926_/B1 _6783_/Q VGND VGND VPWR VPWR _3898_/X sky130_fd_sc_hd__a22o_2
XFILLER_12_47 VGND VGND VPWR VPWR sky130_fd_sc_hd__decap_3
XFILLER_88_18 VGND VGND VPWR VPWR sky130_fd_sc_hd__decap_3
X_5568_ _5568_/A1 _4960_/A _4897_/X VGND VGND VPWR VPWR _7049_/D sky130_fd_sc_hd__a21o_2
X_7307_ _7307_/CLK _7307_/D _6587_/Y VGND VGND VPWR VPWR _7307_/Q sky130_fd_sc_hd__dfrtp_2
X_4519_ _4519_/A1 _3398_/Y _4300_/X VGND VGND VPWR VPWR _7320_/D sky130_fd_sc_hd__a21o_2
XFILLER_104_234 VGND VGND VPWR VPWR sky130_fd_sc_hd__decap_3
XFILLER_78_619 VGND VGND VPWR VPWR sky130_fd_sc_hd__decap_3
X_7238_ _7393_/CLK _7238_/D _6518_/Y VGND VGND VPWR VPWR _7238_/Q sky130_fd_sc_hd__dfrtp_2
XFILLER_77_107 VGND VGND VPWR VPWR sky130_fd_sc_hd__decap_3
XFILLER_77_118 VGND VGND VPWR VPWR sky130_fd_sc_hd__fill_2
XFILLER_77_129 VGND VGND VPWR VPWR sky130_fd_sc_hd__decap_3
XFILLER_58_321 VGND VGND VPWR VPWR sky130_fd_sc_hd__fill_1
XFILLER_58_332 VGND VGND VPWR VPWR sky130_fd_sc_hd__decap_3
XFILLER_86_630 VGND VGND VPWR VPWR sky130_fd_sc_hd__decap_3
X_7169_ _7363_/CLK _7169_/D _6449_/Y VGND VGND VPWR VPWR _7169_/Q sky130_fd_sc_hd__dfrtp_2
XFILLER_37_33 VGND VGND VPWR VPWR sky130_fd_sc_hd__decap_3
XFILLER_58_365 VGND VGND VPWR VPWR sky130_fd_sc_hd__decap_3
XFILLER_85_151 VGND VGND VPWR VPWR sky130_fd_sc_hd__fill_1
XFILLER_18_218 VGND VGND VPWR VPWR sky130_fd_sc_hd__decap_3
XFILLER_37_55 VGND VGND VPWR VPWR sky130_fd_sc_hd__fill_1
XFILLER_37_66 VGND VGND VPWR VPWR sky130_fd_sc_hd__fill_1
XFILLER_73_313 VGND VGND VPWR VPWR sky130_fd_sc_hd__decap_3
XFILLER_26_240 VGND VGND VPWR VPWR sky130_fd_sc_hd__decap_3
XFILLER_37_88 VGND VGND VPWR VPWR sky130_fd_sc_hd__fill_2
XFILLER_61_508 VGND VGND VPWR VPWR sky130_fd_sc_hd__decap_3
XFILLER_73_346 VGND VGND VPWR VPWR sky130_fd_sc_hd__decap_3
XFILLER_73_368 VGND VGND VPWR VPWR sky130_fd_sc_hd__decap_3
XFILLER_14_402 VGND VGND VPWR VPWR sky130_fd_sc_hd__fill_1
XFILLER_26_284 VGND VGND VPWR VPWR sky130_fd_sc_hd__decap_3
XFILLER_41_221 VGND VGND VPWR VPWR sky130_fd_sc_hd__decap_3
XFILLER_41_232 VGND VGND VPWR VPWR sky130_fd_sc_hd__decap_3
XFILLER_53_21 VGND VGND VPWR VPWR sky130_fd_sc_hd__decap_3
XFILLER_53_54 VGND VGND VPWR VPWR sky130_fd_sc_hd__fill_2
XFILLER_41_265 VGND VGND VPWR VPWR sky130_fd_sc_hd__decap_3
XFILLER_53_87 VGND VGND VPWR VPWR sky130_fd_sc_hd__decap_3
XFILLER_41_287 VGND VGND VPWR VPWR sky130_fd_sc_hd__decap_3
XFILLER_10_641 VGND VGND VPWR VPWR sky130_fd_sc_hd__decap_3
Xclkbuf_leaf_21_clk clkbuf_3_6__f_clk/X VGND VGND VPWR VPWR _7394_/CLK sky130_fd_sc_hd__clkbuf_16
XFILLER_5_122 VGND VGND VPWR VPWR sky130_fd_sc_hd__decap_3
XFILLER_6_645 VGND VGND VPWR VPWR sky130_fd_sc_hd__fill_2
XFILLER_108_551 VGND VGND VPWR VPWR sky130_fd_sc_hd__decap_3
XFILLER_5_155 VGND VGND VPWR VPWR sky130_fd_sc_hd__decap_3
XFILLER_108_595 VGND VGND VPWR VPWR sky130_fd_sc_hd__decap_3
XTAP_TAPCELL_ROW_114_1624 VGND VPWR sky130_fd_sc_hd__tapvpwrvgnd_1
XFILLER_5_199 VGND VGND VPWR VPWR sky130_fd_sc_hd__decap_3
XFILLER_78_40 VGND VGND VPWR VPWR sky130_fd_sc_hd__decap_3
XFILLER_68_107 VGND VGND VPWR VPWR sky130_fd_sc_hd__decap_3
XFILLER_96_427 VGND VGND VPWR VPWR sky130_fd_sc_hd__decap_3
XFILLER_110_248 VGND VGND VPWR VPWR sky130_fd_sc_hd__decap_3
XFILLER_49_321 VGND VGND VPWR VPWR sky130_fd_sc_hd__decap_3
XFILLER_49_343 VGND VGND VPWR VPWR sky130_fd_sc_hd__decap_3
XFILLER_49_376 VGND VGND VPWR VPWR sky130_fd_sc_hd__decap_3
XFILLER_64_302 VGND VGND VPWR VPWR sky130_fd_sc_hd__decap_3
XFILLER_64_324 VGND VGND VPWR VPWR sky130_fd_sc_hd__decap_3
XFILLER_91_110 VGND VGND VPWR VPWR sky130_fd_sc_hd__fill_2
XFILLER_92_622 VGND VGND VPWR VPWR sky130_fd_sc_hd__decap_3
XFILLER_94_50 VGND VGND VPWR VPWR sky130_fd_sc_hd__fill_1
XFILLER_64_357 VGND VGND VPWR VPWR sky130_fd_sc_hd__fill_1
XFILLER_64_368 VGND VGND VPWR VPWR sky130_fd_sc_hd__decap_3
XFILLER_76_195 VGND VGND VPWR VPWR sky130_fd_sc_hd__fill_1
XFILLER_94_94 VGND VGND VPWR VPWR sky130_fd_sc_hd__decap_3
XFILLER_17_251 VGND VGND VPWR VPWR sky130_fd_sc_hd__decap_3
XFILLER_91_165 VGND VGND VPWR VPWR sky130_fd_sc_hd__decap_3
XFILLER_32_210 VGND VGND VPWR VPWR sky130_fd_sc_hd__decap_3
XFILLER_91_198 VGND VGND VPWR VPWR sky130_fd_sc_hd__decap_3
X_4870_ _4870_/A _4870_/B VGND VGND VPWR VPWR _4870_/Y sky130_fd_sc_hd__nor2_2
X_3821_ _3746_/C _3819_/X _3820_/X _3864_/S VGND VGND VPWR VPWR _5010_/C sky130_fd_sc_hd__o31a_2
XTAP_TAPCELL_ROW_15_430 VGND VPWR sky130_fd_sc_hd__tapvpwrvgnd_1
XFILLER_20_427 VGND VGND VPWR VPWR sky130_fd_sc_hd__fill_2
X_6540_ _6540_/A VGND VGND VPWR VPWR _6540_/Y sky130_fd_sc_hd__inv_2
XTAP_TAPCELL_ROW_43_772 VGND VPWR sky130_fd_sc_hd__tapvpwrvgnd_1
Xclkbuf_leaf_12_clk clkload0/A VGND VGND VPWR VPWR _7307_/CLK sky130_fd_sc_hd__clkbuf_16
X_3752_ _6799_/Q _3922_/A2 _3863_/A2 _6709_/Q _3751_/X VGND VGND VPWR VPWR _3752_/X
+ sky130_fd_sc_hd__a221o_2
X_6471_ _6634_/A VGND VGND VPWR VPWR _6471_/Y sky130_fd_sc_hd__inv_2
X_3683_ _3672_/X _3673_/X _3864_/S _3682_/Y VGND VGND VPWR VPWR _3683_/Y sky130_fd_sc_hd__o211ai_2
XFILLER_114_510 VGND VGND VPWR VPWR sky130_fd_sc_hd__decap_3
X_4304_ _7256_/Q _3358_/X _4303_/X VGND VGND VPWR VPWR _4364_/A sky130_fd_sc_hd__a21oi_2
XFILLER_99_243 VGND VGND VPWR VPWR sky130_fd_sc_hd__decap_3
XFILLER_101_204 VGND VGND VPWR VPWR sky130_fd_sc_hd__decap_3
XFILLER_114_587 VGND VGND VPWR VPWR sky130_fd_sc_hd__fill_1
XFILLER_87_405 VGND VGND VPWR VPWR sky130_fd_sc_hd__fill_2
X_5284_ _5284_/A0 _5135_/X _5292_/S VGND VGND VPWR VPWR _7187_/D sky130_fd_sc_hd__mux2_2
XFILLER_99_287 VGND VGND VPWR VPWR sky130_fd_sc_hd__decap_3
XFILLER_99_276 VGND VGND VPWR VPWR sky130_fd_sc_hd__decap_3
XFILLER_101_237 VGND VGND VPWR VPWR sky130_fd_sc_hd__decap_3
XFILLER_68_641 VGND VGND VPWR VPWR sky130_fd_sc_hd__decap_3
XFILLER_87_449 VGND VGND VPWR VPWR sky130_fd_sc_hd__decap_3
X_7023_ _7362_/CLK _7023_/D _6303_/Y VGND VGND VPWR VPWR _7023_/Q sky130_fd_sc_hd__dfrtp_2
X_4235_ _7227_/Q _4340_/A2 _4348_/B1 _7131_/Q VGND VGND VPWR VPWR _4235_/X sky130_fd_sc_hd__a22o_2
XFILLER_114_27 VGND VGND VPWR VPWR sky130_fd_sc_hd__fill_1
XFILLER_83_600 VGND VGND VPWR VPWR sky130_fd_sc_hd__decap_3
X_4166_ _7233_/Q _4414_/A2 _3958_/S _7201_/Q VGND VGND VPWR VPWR _4166_/X sky130_fd_sc_hd__a22o_2
XFILLER_55_324 VGND VGND VPWR VPWR sky130_fd_sc_hd__decap_3
XFILLER_67_162 VGND VGND VPWR VPWR sky130_fd_sc_hd__decap_3
XFILLER_95_482 VGND VGND VPWR VPWR sky130_fd_sc_hd__decap_3
XFILLER_55_346 VGND VGND VPWR VPWR sky130_fd_sc_hd__decap_3
XFILLER_83_655 VGND VGND VPWR VPWR sky130_fd_sc_hd__decap_3
XFILLER_55_379 VGND VGND VPWR VPWR sky130_fd_sc_hd__decap_3
XFILLER_82_165 VGND VGND VPWR VPWR sky130_fd_sc_hd__decap_3
XFILLER_70_338 VGND VGND VPWR VPWR sky130_fd_sc_hd__decap_3
XFILLER_23_254 VGND VGND VPWR VPWR sky130_fd_sc_hd__decap_3
Xplace390 _5217_/B VGND VGND VPWR VPWR _5194_/B sky130_fd_sc_hd__buf_2
X_6807_ _6966_/CLK _6807_/D VGND VGND VPWR VPWR _6807_/Q sky130_fd_sc_hd__dfxtp_2
XFILLER_23_24 VGND VGND VPWR VPWR sky130_fd_sc_hd__decap_3
XFILLER_109_304 VGND VGND VPWR VPWR sky130_fd_sc_hd__decap_3
XFILLER_23_57 VGND VGND VPWR VPWR sky130_fd_sc_hd__decap_3
X_6738_ _6909_/CLK _6738_/D VGND VGND VPWR VPWR _6738_/Q sky130_fd_sc_hd__dfxtp_2
XFILLER_109_337 VGND VGND VPWR VPWR sky130_fd_sc_hd__decap_3
X_6669_ _6672_/A VGND VGND VPWR VPWR _6669_/Y sky130_fd_sc_hd__inv_2
XTAP_TAPCELL_ROW_21_499 VGND VPWR sky130_fd_sc_hd__tapvpwrvgnd_1
XFILLER_105_554 VGND VGND VPWR VPWR sky130_fd_sc_hd__decap_3
XFILLER_2_114 VGND VGND VPWR VPWR sky130_fd_sc_hd__decap_3
XFILLER_2_136 VGND VGND VPWR VPWR sky130_fd_sc_hd__decap_3
XFILLER_2_147 VGND VGND VPWR VPWR sky130_fd_sc_hd__fill_2
XFILLER_48_32 VGND VGND VPWR VPWR sky130_fd_sc_hd__decap_3
XFILLER_78_449 VGND VGND VPWR VPWR sky130_fd_sc_hd__decap_3
XFILLER_19_505 VGND VGND VPWR VPWR sky130_fd_sc_hd__fill_1
XFILLER_93_408 VGND VGND VPWR VPWR sky130_fd_sc_hd__decap_3
XFILLER_46_324 VGND VGND VPWR VPWR sky130_fd_sc_hd__decap_3
XFILLER_58_162 VGND VGND VPWR VPWR sky130_fd_sc_hd__decap_3
XFILLER_100_292 VGND VGND VPWR VPWR sky130_fd_sc_hd__decap_3
XFILLER_104_71 VGND VGND VPWR VPWR sky130_fd_sc_hd__decap_3
XFILLER_34_508 VGND VGND VPWR VPWR sky130_fd_sc_hd__decap_3
XFILLER_46_357 VGND VGND VPWR VPWR sky130_fd_sc_hd__decap_3
XFILLER_73_132 VGND VGND VPWR VPWR sky130_fd_sc_hd__decap_3
XFILLER_46_368 VGND VGND VPWR VPWR sky130_fd_sc_hd__decap_3
XFILLER_61_327 VGND VGND VPWR VPWR sky130_fd_sc_hd__decap_3
XFILLER_64_53 VGND VGND VPWR VPWR sky130_fd_sc_hd__decap_3
XFILLER_27_593 VGND VGND VPWR VPWR sky130_fd_sc_hd__decap_3
XFILLER_61_349 VGND VGND VPWR VPWR sky130_fd_sc_hd__decap_3
XFILLER_64_75 VGND VGND VPWR VPWR sky130_fd_sc_hd__decap_3
XFILLER_73_187 VGND VGND VPWR VPWR sky130_fd_sc_hd__decap_3
XTAP_TAPCELL_ROW_64_1022 VGND VPWR sky130_fd_sc_hd__tapvpwrvgnd_1
XTAP_TAPCELL_ROW_29_599 VGND VPWR sky130_fd_sc_hd__tapvpwrvgnd_1
XFILLER_14_243 VGND VGND VPWR VPWR sky130_fd_sc_hd__decap_3
XFILLER_14_265 VGND VGND VPWR VPWR sky130_fd_sc_hd__fill_1
XFILLER_14_287 VGND VGND VPWR VPWR sky130_fd_sc_hd__decap_3
XFILLER_42_585 VGND VGND VPWR VPWR sky130_fd_sc_hd__decap_3
XFILLER_80_41 VGND VGND VPWR VPWR sky130_fd_sc_hd__decap_3
XTAP_TAPCELL_ROW_12_400 VGND VPWR sky130_fd_sc_hd__tapvpwrvgnd_1
XFILLER_9_37 VGND VGND VPWR VPWR sky130_fd_sc_hd__fill_2
XTAP_TAPCELL_ROW_40_731 VGND VPWR sky130_fd_sc_hd__tapvpwrvgnd_1
XFILLER_10_471 VGND VGND VPWR VPWR sky130_fd_sc_hd__decap_3
XFILLER_80_85 VGND VGND VPWR VPWR sky130_fd_sc_hd__decap_3
XFILLER_6_431 VGND VGND VPWR VPWR sky130_fd_sc_hd__decap_3
XFILLER_115_329 VGND VGND VPWR VPWR sky130_fd_sc_hd__decap_3
XFILLER_108_392 VGND VGND VPWR VPWR sky130_fd_sc_hd__decap_3
XFILLER_89_72 VGND VGND VPWR VPWR sky130_fd_sc_hd__decap_3
XTAP_TAPCELL_ROW_75_1151 VGND VPWR sky130_fd_sc_hd__tapvpwrvgnd_1
XFILLER_69_405 VGND VGND VPWR VPWR sky130_fd_sc_hd__decap_3
XFILLER_69_438 VGND VGND VPWR VPWR sky130_fd_sc_hd__decap_3
XFILLER_69_449 VGND VGND VPWR VPWR sky130_fd_sc_hd__decap_3
XFILLER_96_224 VGND VGND VPWR VPWR sky130_fd_sc_hd__decap_3
XFILLER_96_246 VGND VGND VPWR VPWR sky130_fd_sc_hd__decap_3
XFILLER_111_557 VGND VGND VPWR VPWR sky130_fd_sc_hd__decap_3
XFILLER_49_140 VGND VGND VPWR VPWR sky130_fd_sc_hd__decap_3
XFILLER_84_408 VGND VGND VPWR VPWR sky130_fd_sc_hd__decap_3
XFILLER_96_268 VGND VGND VPWR VPWR sky130_fd_sc_hd__decap_3
Xclkbuf_leaf_1_clk clkbuf_leaf_1_clk/A VGND VGND VPWR VPWR clkload6/A sky130_fd_sc_hd__clkbuf_16
X_4020_ _7086_/Q _4432_/A2 _4432_/B1 _4019_/X VGND VGND VPWR VPWR _4039_/A sky130_fd_sc_hd__o211ai_2
XFILLER_37_302 VGND VGND VPWR VPWR sky130_fd_sc_hd__decap_3
XFILLER_49_184 VGND VGND VPWR VPWR sky130_fd_sc_hd__decap_3
XFILLER_77_460 VGND VGND VPWR VPWR sky130_fd_sc_hd__decap_3
XFILLER_77_493 VGND VGND VPWR VPWR sky130_fd_sc_hd__fill_2
XFILLER_64_132 VGND VGND VPWR VPWR sky130_fd_sc_hd__decap_3
XFILLER_92_452 VGND VGND VPWR VPWR sky130_fd_sc_hd__decap_3
XTAP_TAPCELL_ROW_48_831 VGND VPWR sky130_fd_sc_hd__tapvpwrvgnd_1
XFILLER_52_305 VGND VGND VPWR VPWR sky130_fd_sc_hd__decap_3
XFILLER_52_327 VGND VGND VPWR VPWR sky130_fd_sc_hd__decap_3
XFILLER_80_658 VGND VGND VPWR VPWR sky130_fd_sc_hd__decap_3
X_4922_ _4937_/A _4937_/B _4203_/X VGND VGND VPWR VPWR _4922_/X sky130_fd_sc_hd__a21o_2
XTAP_TAPCELL_ROW_86_1280 VGND VPWR sky130_fd_sc_hd__tapvpwrvgnd_1
XFILLER_100_29 VGND VGND VPWR VPWR sky130_fd_sc_hd__decap_3
XFILLER_60_382 VGND VGND VPWR VPWR sky130_fd_sc_hd__decap_3
X_4784_ _4813_/A _4829_/B VGND VGND VPWR VPWR _4811_/B sky130_fd_sc_hd__nand2_2
X_3804_ _6826_/Q _3869_/A2 _3913_/B1 _6811_/Q _3803_/X VGND VGND VPWR VPWR _3804_/X
+ sky130_fd_sc_hd__a221o_2
X_6523_ _6523_/A VGND VGND VPWR VPWR _6523_/Y sky130_fd_sc_hd__inv_2
X_3735_ _3735_/A _3746_/B _3746_/C VGND VGND VPWR VPWR _3735_/X sky130_fd_sc_hd__and3_4
X_6454_ _6675_/A VGND VGND VPWR VPWR _6454_/Y sky130_fd_sc_hd__inv_2
XFILLER_106_318 VGND VGND VPWR VPWR sky130_fd_sc_hd__decap_3
XFILLER_109_49 VGND VGND VPWR VPWR sky130_fd_sc_hd__decap_3
X_6385_ _6385_/A VGND VGND VPWR VPWR _6385_/Y sky130_fd_sc_hd__inv_2
X_3597_ _4295_/B _3607_/B VGND VGND VPWR VPWR _3611_/B sky130_fd_sc_hd__nor2_2
XFILLER_102_502 VGND VGND VPWR VPWR sky130_fd_sc_hd__decap_3
X_5336_ _5336_/A0 _5040_/X _5360_/S VGND VGND VPWR VPWR _7163_/D sky130_fd_sc_hd__mux2_2
XFILLER_87_235 VGND VGND VPWR VPWR sky130_fd_sc_hd__decap_3
XFILLER_87_268 VGND VGND VPWR VPWR sky130_fd_sc_hd__decap_3
X_7006_ _7368_/CLK _7006_/D _6286_/Y VGND VGND VPWR VPWR _7006_/Q sky130_fd_sc_hd__dfrtp_2
X_4218_ _7100_/Q _4218_/A2 _4351_/B1 _7132_/Q VGND VGND VPWR VPWR _4218_/X sky130_fd_sc_hd__a22o_2
XFILLER_18_35 VGND VGND VPWR VPWR sky130_fd_sc_hd__decap_3
XFILLER_28_324 VGND VGND VPWR VPWR sky130_fd_sc_hd__decap_3
X_5198_ _5198_/A _5217_/B VGND VGND VPWR VPWR _7229_/D sky130_fd_sc_hd__and2_2
XFILLER_55_132 VGND VGND VPWR VPWR sky130_fd_sc_hd__decap_3
XFILLER_56_655 VGND VGND VPWR VPWR sky130_fd_sc_hd__fill_1
X_4149_ _4205_/A _4205_/B VGND VGND VPWR VPWR _4157_/A sky130_fd_sc_hd__nand2_2
XFILLER_28_368 VGND VGND VPWR VPWR sky130_fd_sc_hd__decap_3
XFILLER_43_305 VGND VGND VPWR VPWR sky130_fd_sc_hd__decap_3
XFILLER_55_154 VGND VGND VPWR VPWR sky130_fd_sc_hd__decap_3
XFILLER_43_327 VGND VGND VPWR VPWR sky130_fd_sc_hd__decap_3
XFILLER_43_349 VGND VGND VPWR VPWR sky130_fd_sc_hd__fill_2
XFILLER_55_198 VGND VGND VPWR VPWR sky130_fd_sc_hd__decap_3
XFILLER_71_647 VGND VGND VPWR VPWR sky130_fd_sc_hd__decap_3
XFILLER_70_157 VGND VGND VPWR VPWR sky130_fd_sc_hd__decap_3
XFILLER_71_669 VGND VGND VPWR VPWR sky130_fd_sc_hd__decap_3
XTAP_TAPCELL_ROW_26_569 VGND VPWR sky130_fd_sc_hd__tapvpwrvgnd_1
XTAP_TAPCELL_ROW_26_558 VGND VPWR sky130_fd_sc_hd__tapvpwrvgnd_1
XFILLER_34_78 VGND VGND VPWR VPWR sky130_fd_sc_hd__decap_3
XFILLER_11_246 VGND VGND VPWR VPWR sky130_fd_sc_hd__decap_3
XFILLER_51_393 VGND VGND VPWR VPWR sky130_fd_sc_hd__decap_3
XFILLER_11_279 VGND VGND VPWR VPWR sky130_fd_sc_hd__fill_1
XFILLER_50_22 VGND VGND VPWR VPWR sky130_fd_sc_hd__decap_3
XFILLER_7_217 VGND VGND VPWR VPWR sky130_fd_sc_hd__decap_3
XFILLER_7_228 VGND VGND VPWR VPWR sky130_fd_sc_hd__decap_3
Xclkload0 clkload0/A VGND VGND VPWR VPWR clkload0/X sky130_fd_sc_hd__clkbuf_16
XFILLER_50_55 VGND VGND VPWR VPWR sky130_fd_sc_hd__decap_3
XFILLER_50_88 VGND VGND VPWR VPWR sky130_fd_sc_hd__decap_3
XFILLER_105_340 VGND VGND VPWR VPWR sky130_fd_sc_hd__decap_3
XFILLER_59_42 VGND VGND VPWR VPWR sky130_fd_sc_hd__fill_2
XFILLER_66_419 VGND VGND VPWR VPWR sky130_fd_sc_hd__fill_1
XFILLER_19_302 VGND VGND VPWR VPWR sky130_fd_sc_hd__decap_3
XTAP_TAPCELL_ROW_70_1092 VGND VPWR sky130_fd_sc_hd__tapvpwrvgnd_1
XFILLER_101_590 VGND VGND VPWR VPWR sky130_fd_sc_hd__decap_3
XFILLER_19_335 VGND VGND VPWR VPWR sky130_fd_sc_hd__fill_1
XFILLER_19_346 VGND VGND VPWR VPWR sky130_fd_sc_hd__decap_3
XFILLER_46_121 VGND VGND VPWR VPWR sky130_fd_sc_hd__decap_3
XFILLER_75_52 VGND VGND VPWR VPWR sky130_fd_sc_hd__decap_3
XFILLER_75_63 VGND VGND VPWR VPWR sky130_fd_sc_hd__fill_1
XFILLER_46_176 VGND VGND VPWR VPWR sky130_fd_sc_hd__decap_3
XFILLER_74_452 VGND VGND VPWR VPWR sky130_fd_sc_hd__decap_3
XFILLER_75_74 VGND VGND VPWR VPWR sky130_fd_sc_hd__decap_3
XTAP_TAPCELL_ROW_109_1556 VGND VPWR sky130_fd_sc_hd__tapvpwrvgnd_1
XFILLER_61_102 VGND VGND VPWR VPWR sky130_fd_sc_hd__decap_3
XFILLER_61_113 VGND VGND VPWR VPWR sky130_fd_sc_hd__decap_3
XFILLER_74_496 VGND VGND VPWR VPWR sky130_fd_sc_hd__decap_3
XFILLER_61_146 VGND VGND VPWR VPWR sky130_fd_sc_hd__decap_3
XFILLER_91_40 VGND VGND VPWR VPWR sky130_fd_sc_hd__decap_3
XFILLER_15_596 VGND VGND VPWR VPWR sky130_fd_sc_hd__decap_3
XFILLER_30_511 VGND VGND VPWR VPWR sky130_fd_sc_hd__decap_3
XFILLER_42_360 VGND VGND VPWR VPWR sky130_fd_sc_hd__decap_3
XFILLER_30_577 VGND VGND VPWR VPWR sky130_fd_sc_hd__decap_3
X_3520_ _5118_/D _3354_/X _3519_/Y _3350_/B VGND VGND VPWR VPWR _3525_/B sky130_fd_sc_hd__o2bb2a_2
XFILLER_116_638 VGND VGND VPWR VPWR sky130_fd_sc_hd__decap_3
Xhold707 _6774_/Q VGND VGND VPWR VPWR _6774_/D sky130_fd_sc_hd__dlygate4sd3_1
Xhold718 _6845_/Q VGND VGND VPWR VPWR _6845_/D sky130_fd_sc_hd__dlygate4sd3_1
XFILLER_6_272 VGND VGND VPWR VPWR sky130_fd_sc_hd__decap_3
XFILLER_6_294 VGND VGND VPWR VPWR sky130_fd_sc_hd__decap_3
Xhold729 _6761_/Q VGND VGND VPWR VPWR _6761_/D sky130_fd_sc_hd__dlygate4sd3_1
XFILLER_97_500 VGND VGND VPWR VPWR sky130_fd_sc_hd__decap_3
XFILLER_111_321 VGND VGND VPWR VPWR sky130_fd_sc_hd__decap_3
XFILLER_69_213 VGND VGND VPWR VPWR sky130_fd_sc_hd__decap_3
XFILLER_97_544 VGND VGND VPWR VPWR sky130_fd_sc_hd__decap_3
X_5121_ _5092_/C _5117_/X _5118_/X _6984_/D _5666_/A VGND VGND VPWR VPWR _5121_/X
+ sky130_fd_sc_hd__a32o_2
XFILLER_57_408 VGND VGND VPWR VPWR sky130_fd_sc_hd__decap_3
XFILLER_69_246 VGND VGND VPWR VPWR sky130_fd_sc_hd__decap_3
XFILLER_97_577 VGND VGND VPWR VPWR sky130_fd_sc_hd__decap_3
XFILLER_69_279 VGND VGND VPWR VPWR sky130_fd_sc_hd__fill_1
XFILLER_84_216 VGND VGND VPWR VPWR sky130_fd_sc_hd__decap_3
X_5052_ _3548_/X _5049_/X _5051_/X _3618_/X VGND VGND VPWR VPWR _5052_/X sky130_fd_sc_hd__a2bb2o_2
XFILLER_65_441 VGND VGND VPWR VPWR sky130_fd_sc_hd__decap_3
XFILLER_25_305 VGND VGND VPWR VPWR sky130_fd_sc_hd__decap_3
XFILLER_37_143 VGND VGND VPWR VPWR sky130_fd_sc_hd__decap_3
XFILLER_65_452 VGND VGND VPWR VPWR sky130_fd_sc_hd__decap_3
XFILLER_80_400 VGND VGND VPWR VPWR sky130_fd_sc_hd__decap_3
XFILLER_111_28 VGND VGND VPWR VPWR sky130_fd_sc_hd__decap_3
XFILLER_25_349 VGND VGND VPWR VPWR sky130_fd_sc_hd__decap_3
XFILLER_37_187 VGND VGND VPWR VPWR sky130_fd_sc_hd__decap_3
XFILLER_80_433 VGND VGND VPWR VPWR sky130_fd_sc_hd__decap_3
XFILLER_18_390 VGND VGND VPWR VPWR sky130_fd_sc_hd__decap_3
XFILLER_52_168 VGND VGND VPWR VPWR sky130_fd_sc_hd__decap_3
XFILLER_80_477 VGND VGND VPWR VPWR sky130_fd_sc_hd__decap_3
XFILLER_61_691 VGND VGND VPWR VPWR sky130_fd_sc_hd__fill_1
X_4905_ _4891_/A1 _4888_/A _4903_/A _5101_/A VGND VGND VPWR VPWR _4905_/X sky130_fd_sc_hd__o2bb2a_2
XTAP_TAPCELL_ROW_23_528 VGND VPWR sky130_fd_sc_hd__tapvpwrvgnd_1
X_4836_ _7001_/D _4835_/X _4836_/S VGND VGND VPWR VPWR _4836_/X sky130_fd_sc_hd__mux2_2
XTAP_TAPCELL_ROW_51_859 VGND VPWR sky130_fd_sc_hd__tapvpwrvgnd_1
X_6506_ _6535_/A VGND VGND VPWR VPWR _6506_/Y sky130_fd_sc_hd__inv_2
X_4767_ _5057_/A _4452_/A _4453_/A _4852_/A _4766_/Y VGND VGND VPWR VPWR _4767_/X
+ sky130_fd_sc_hd__o221a_2
XFILLER_107_638 VGND VGND VPWR VPWR sky130_fd_sc_hd__decap_3
XFILLER_4_209 VGND VGND VPWR VPWR sky130_fd_sc_hd__decap_3
X_4698_ _6985_/Q _5120_/A VGND VGND VPWR VPWR _5098_/A sky130_fd_sc_hd__and2_2
XFILLER_20_47 VGND VGND VPWR VPWR sky130_fd_sc_hd__decap_3
X_6437_ _6570_/A VGND VGND VPWR VPWR _6437_/Y sky130_fd_sc_hd__inv_2
X_6368_ _6567_/A VGND VGND VPWR VPWR _6368_/Y sky130_fd_sc_hd__inv_2
XFILLER_102_321 VGND VGND VPWR VPWR sky130_fd_sc_hd__decap_3
XFILLER_88_522 VGND VGND VPWR VPWR sky130_fd_sc_hd__decap_3
XFILLER_88_533 VGND VGND VPWR VPWR sky130_fd_sc_hd__decap_3
XFILLER_96_29 VGND VGND VPWR VPWR sky130_fd_sc_hd__decap_3
X_5319_ _5319_/A0 _4913_/X _5327_/S VGND VGND VPWR VPWR _7171_/D sky130_fd_sc_hd__mux2_2
XFILLER_102_354 VGND VGND VPWR VPWR sky130_fd_sc_hd__decap_3
XFILLER_29_23 VGND VGND VPWR VPWR sky130_fd_sc_hd__decap_3
X_6299_ _6366_/A VGND VGND VPWR VPWR _6299_/Y sky130_fd_sc_hd__inv_2
XFILLER_102_365 VGND VGND VPWR VPWR sky130_fd_sc_hd__decap_3
XFILLER_102_387 VGND VGND VPWR VPWR sky130_fd_sc_hd__decap_3
XFILLER_29_78 VGND VGND VPWR VPWR sky130_fd_sc_hd__decap_3
XFILLER_48_419 VGND VGND VPWR VPWR sky130_fd_sc_hd__fill_1
XFILLER_75_205 VGND VGND VPWR VPWR sky130_fd_sc_hd__fill_1
XFILLER_75_216 VGND VGND VPWR VPWR sky130_fd_sc_hd__decap_3
XFILLER_28_110 VGND VGND VPWR VPWR sky130_fd_sc_hd__decap_3
XFILLER_56_430 VGND VGND VPWR VPWR sky130_fd_sc_hd__fill_1
XFILLER_75_249 VGND VGND VPWR VPWR sky130_fd_sc_hd__decap_3
XTAP_TAPCELL_ROW_59_959 VGND VPWR sky130_fd_sc_hd__tapvpwrvgnd_1
XFILLER_28_165 VGND VGND VPWR VPWR sky130_fd_sc_hd__decap_3
XFILLER_45_11 VGND VGND VPWR VPWR sky130_fd_sc_hd__decap_3
XFILLER_56_452 VGND VGND VPWR VPWR sky130_fd_sc_hd__fill_1
XFILLER_90_219 VGND VGND VPWR VPWR sky130_fd_sc_hd__decap_3
XTAP_TAPCELL_ROW_3_286 VGND VPWR sky130_fd_sc_hd__tapvpwrvgnd_1
XFILLER_43_113 VGND VGND VPWR VPWR sky130_fd_sc_hd__decap_3
XFILLER_71_411 VGND VGND VPWR VPWR sky130_fd_sc_hd__decap_3
XFILLER_43_157 VGND VGND VPWR VPWR sky130_fd_sc_hd__decap_3
XFILLER_45_88 VGND VGND VPWR VPWR sky130_fd_sc_hd__decap_3
XFILLER_71_455 VGND VGND VPWR VPWR sky130_fd_sc_hd__decap_3
XFILLER_24_371 VGND VGND VPWR VPWR sky130_fd_sc_hd__decap_3
XFILLER_101_72 VGND VGND VPWR VPWR sky130_fd_sc_hd__decap_3
XFILLER_52_691 VGND VGND VPWR VPWR sky130_fd_sc_hd__fill_1
XFILLER_61_21 VGND VGND VPWR VPWR sky130_fd_sc_hd__decap_3
XTAP_TAPCELL_ROW_104_1497 VGND VPWR sky130_fd_sc_hd__tapvpwrvgnd_1
XFILLER_6_16 VGND VGND VPWR VPWR sky130_fd_sc_hd__decap_3
XANTENNA_9 _4073_/X VGND VGND VPWR VPWR sky130_fd_sc_hd__diode_2
XFILLER_6_27 VGND VGND VPWR VPWR sky130_fd_sc_hd__fill_1
XFILLER_106_660 VGND VGND VPWR VPWR sky130_fd_sc_hd__decap_3
XFILLER_79_500 VGND VGND VPWR VPWR sky130_fd_sc_hd__fill_1
XTAP_TAPCELL_ROW_72_1110 VGND VPWR sky130_fd_sc_hd__tapvpwrvgnd_1
XFILLER_3_264 VGND VGND VPWR VPWR sky130_fd_sc_hd__decap_3
XFILLER_79_522 VGND VGND VPWR VPWR sky130_fd_sc_hd__decap_3
XTAP_TAPCELL_ROW_72_1121 VGND VPWR sky130_fd_sc_hd__tapvpwrvgnd_1
XFILLER_105_181 VGND VGND VPWR VPWR sky130_fd_sc_hd__decap_3
XFILLER_39_408 VGND VGND VPWR VPWR sky130_fd_sc_hd__decap_3
XFILLER_79_577 VGND VGND VPWR VPWR sky130_fd_sc_hd__decap_3
XFILLER_66_227 VGND VGND VPWR VPWR sky130_fd_sc_hd__decap_3
XFILLER_79_599 VGND VGND VPWR VPWR sky130_fd_sc_hd__fill_2
XFILLER_86_62 VGND VGND VPWR VPWR sky130_fd_sc_hd__decap_3
XFILLER_94_536 VGND VGND VPWR VPWR sky130_fd_sc_hd__decap_3
XFILLER_59_290 VGND VGND VPWR VPWR sky130_fd_sc_hd__decap_3
XFILLER_47_452 VGND VGND VPWR VPWR sky130_fd_sc_hd__decap_3
XFILLER_62_400 VGND VGND VPWR VPWR sky130_fd_sc_hd__decap_3
XFILLER_81_208 VGND VGND VPWR VPWR sky130_fd_sc_hd__decap_3
XFILLER_62_433 VGND VGND VPWR VPWR sky130_fd_sc_hd__decap_3
XFILLER_34_135 VGND VGND VPWR VPWR sky130_fd_sc_hd__decap_3
XFILLER_34_146 VGND VGND VPWR VPWR sky130_fd_sc_hd__decap_3
XFILLER_62_466 VGND VGND VPWR VPWR sky130_fd_sc_hd__decap_3
XFILLER_34_179 VGND VGND VPWR VPWR sky130_fd_sc_hd__decap_3
XFILLER_62_477 VGND VGND VPWR VPWR sky130_fd_sc_hd__decap_3
XTAP_TAPCELL_ROW_83_1250 VGND VPWR sky130_fd_sc_hd__tapvpwrvgnd_1
X_5670_ _6983_/Q _5670_/B VGND VGND VPWR VPWR _5671_/B sky130_fd_sc_hd__nand2_2
XFILLER_30_341 VGND VGND VPWR VPWR sky130_fd_sc_hd__decap_3
XFILLER_89_3 VGND VGND VPWR VPWR sky130_fd_sc_hd__decap_3
X_4621_ _4315_/B _4343_/X _4315_/A VGND VGND VPWR VPWR _4621_/X sky130_fd_sc_hd__a21bo_2
XFILLER_116_402 VGND VGND VPWR VPWR sky130_fd_sc_hd__decap_3
X_7340_ _7340_/CLK _7340_/D _6620_/Y VGND VGND VPWR VPWR _7340_/Q sky130_fd_sc_hd__dfrtp_2
X_4552_ _4552_/A _4569_/B VGND VGND VPWR VPWR _7304_/D sky130_fd_sc_hd__and2_2
XFILLER_116_424 VGND VGND VPWR VPWR sky130_fd_sc_hd__decap_3
XFILLER_116_446 VGND VGND VPWR VPWR sky130_fd_sc_hd__fill_2
X_7271_ _7371_/CLK _7271_/D _6551_/Y VGND VGND VPWR VPWR _7271_/Q sky130_fd_sc_hd__dfrtp_2
X_3503_ _3545_/A _3545_/B VGND VGND VPWR VPWR _3630_/A sky130_fd_sc_hd__xor2_4
X_3434_ _7218_/Q _4340_/A2 _4246_/B1 _7122_/Q VGND VGND VPWR VPWR _3434_/X sky130_fd_sc_hd__a22o_2
XFILLER_103_129 VGND VGND VPWR VPWR sky130_fd_sc_hd__decap_3
XFILLER_106_39 VGND VGND VPWR VPWR sky130_fd_sc_hd__decap_3
XFILLER_112_630 VGND VGND VPWR VPWR sky130_fd_sc_hd__decap_3
XFILLER_97_330 VGND VGND VPWR VPWR sky130_fd_sc_hd__decap_3
X_3365_ _3365_/A VGND VGND VPWR VPWR _5118_/A sky130_fd_sc_hd__inv_2
XFILLER_97_363 VGND VGND VPWR VPWR sky130_fd_sc_hd__fill_2
XFILLER_97_385 VGND VGND VPWR VPWR sky130_fd_sc_hd__decap_3
Xhold1204 _7121_/Q VGND VGND VPWR VPWR _5425_/A0 sky130_fd_sc_hd__dlygate4sd3_1
X_5104_ _5104_/A _5660_/C VGND VGND VPWR VPWR _5104_/Y sky130_fd_sc_hd__nand2_2
XFILLER_57_249 VGND VGND VPWR VPWR sky130_fd_sc_hd__decap_3
XFILLER_97_396 VGND VGND VPWR VPWR sky130_fd_sc_hd__decap_3
XFILLER_38_452 VGND VGND VPWR VPWR sky130_fd_sc_hd__decap_3
XTAP_TAPCELL_ROW_56_929 VGND VPWR sky130_fd_sc_hd__tapvpwrvgnd_1
XTAP_TAPCELL_ROW_56_918 VGND VPWR sky130_fd_sc_hd__tapvpwrvgnd_1
XFILLER_25_102 VGND VGND VPWR VPWR sky130_fd_sc_hd__fill_2
XFILLER_25_113 VGND VGND VPWR VPWR sky130_fd_sc_hd__decap_3
XFILLER_65_260 VGND VGND VPWR VPWR sky130_fd_sc_hd__decap_3
XFILLER_93_591 VGND VGND VPWR VPWR sky130_fd_sc_hd__decap_3
XTAP_TAPCELL_ROW_0_245 VGND VPWR sky130_fd_sc_hd__tapvpwrvgnd_1
XTAP_TAPCELL_ROW_0_234 VGND VPWR sky130_fd_sc_hd__tapvpwrvgnd_1
XFILLER_53_444 VGND VGND VPWR VPWR sky130_fd_sc_hd__decap_3
X_6986_ _7396_/CLK _6986_/D _6266_/Y VGND VGND VPWR VPWR _6986_/Q sky130_fd_sc_hd__dfrtp_2
XTAP_TAPCELL_ROW_0_256 VGND VPWR sky130_fd_sc_hd__tapvpwrvgnd_1
XFILLER_15_36 VGND VGND VPWR VPWR sky130_fd_sc_hd__fill_2
XFILLER_53_499 VGND VGND VPWR VPWR sky130_fd_sc_hd__decap_3
XFILLER_80_274 VGND VGND VPWR VPWR sky130_fd_sc_hd__decap_3
XTAP_TAPCELL_ROW_36_686 VGND VPWR sky130_fd_sc_hd__tapvpwrvgnd_1
XFILLER_33_190 VGND VGND VPWR VPWR sky130_fd_sc_hd__decap_3
XFILLER_40_127 VGND VGND VPWR VPWR sky130_fd_sc_hd__decap_3
XFILLER_21_352 VGND VGND VPWR VPWR sky130_fd_sc_hd__fill_2
XFILLER_21_396 VGND VGND VPWR VPWR sky130_fd_sc_hd__fill_1
X_4819_ _7002_/Q _4834_/A _4818_/Y _4983_/A VGND VGND VPWR VPWR _4819_/X sky130_fd_sc_hd__o211a_2
XTAP_TAPCELL_ROW_97_1419 VGND VPWR sky130_fd_sc_hd__tapvpwrvgnd_1
XFILLER_107_413 VGND VGND VPWR VPWR sky130_fd_sc_hd__decap_3
XFILLER_31_57 VGND VGND VPWR VPWR sky130_fd_sc_hd__fill_1
XFILLER_31_68 VGND VGND VPWR VPWR sky130_fd_sc_hd__decap_3
XFILLER_107_446 VGND VGND VPWR VPWR sky130_fd_sc_hd__fill_2
XFILLER_110_6 VGND VGND VPWR VPWR sky130_fd_sc_hd__decap_3
XFILLER_0_212 VGND VGND VPWR VPWR sky130_fd_sc_hd__fill_2
XTAP_TAPCELL_ROW_8_345 VGND VPWR sky130_fd_sc_hd__tapvpwrvgnd_1
XFILLER_0_234 VGND VGND VPWR VPWR sky130_fd_sc_hd__fill_2
XFILLER_103_652 VGND VGND VPWR VPWR sky130_fd_sc_hd__decap_3
XFILLER_88_330 VGND VGND VPWR VPWR sky130_fd_sc_hd__decap_3
XFILLER_0_256 VGND VGND VPWR VPWR sky130_fd_sc_hd__decap_3
XFILLER_0_278 VGND VGND VPWR VPWR sky130_fd_sc_hd__fill_2
XFILLER_76_525 VGND VGND VPWR VPWR sky130_fd_sc_hd__decap_3
XFILLER_88_374 VGND VGND VPWR VPWR sky130_fd_sc_hd__decap_3
XFILLER_48_238 VGND VGND VPWR VPWR sky130_fd_sc_hd__decap_3
XFILLER_56_32 VGND VGND VPWR VPWR sky130_fd_sc_hd__fill_2
XFILLER_76_536 VGND VGND VPWR VPWR sky130_fd_sc_hd__decap_3
XFILLER_76_558 VGND VGND VPWR VPWR sky130_fd_sc_hd__decap_3
XFILLER_88_396 VGND VGND VPWR VPWR sky130_fd_sc_hd__decap_3
XFILLER_56_65 VGND VGND VPWR VPWR sky130_fd_sc_hd__decap_3
XFILLER_63_208 VGND VGND VPWR VPWR sky130_fd_sc_hd__decap_3
XFILLER_63_219 VGND VGND VPWR VPWR sky130_fd_sc_hd__decap_3
XFILLER_91_517 VGND VGND VPWR VPWR sky130_fd_sc_hd__decap_3
XFILLER_16_102 VGND VGND VPWR VPWR sky130_fd_sc_hd__decap_3
XFILLER_44_400 VGND VGND VPWR VPWR sky130_fd_sc_hd__decap_3
XFILLER_56_271 VGND VGND VPWR VPWR sky130_fd_sc_hd__decap_3
XTAP_TAPCELL_ROW_106_1526 VGND VPWR sky130_fd_sc_hd__tapvpwrvgnd_1
XFILLER_44_433 VGND VGND VPWR VPWR sky130_fd_sc_hd__decap_3
XFILLER_44_444 VGND VGND VPWR VPWR sky130_fd_sc_hd__decap_3
XPHY_EDGE_ROW_19_Right_19 VGND VGND VPWR VPWR sky130_fd_sc_hd__decap_3
XFILLER_112_71 VGND VGND VPWR VPWR sky130_fd_sc_hd__decap_3
XFILLER_16_168 VGND VGND VPWR VPWR sky130_fd_sc_hd__decap_3
XFILLER_31_116 VGND VGND VPWR VPWR sky130_fd_sc_hd__decap_3
XFILLER_44_477 VGND VGND VPWR VPWR sky130_fd_sc_hd__decap_3
XFILLER_71_252 VGND VGND VPWR VPWR sky130_fd_sc_hd__decap_3
XFILLER_72_53 VGND VGND VPWR VPWR sky130_fd_sc_hd__decap_3
XFILLER_12_330 VGND VGND VPWR VPWR sky130_fd_sc_hd__decap_3
XFILLER_31_149 VGND VGND VPWR VPWR sky130_fd_sc_hd__fill_2
XFILLER_71_296 VGND VGND VPWR VPWR sky130_fd_sc_hd__decap_3
XFILLER_8_301 VGND VGND VPWR VPWR sky130_fd_sc_hd__decap_3
XFILLER_12_374 VGND VGND VPWR VPWR sky130_fd_sc_hd__decap_3
XFILLER_75_9 VGND VGND VPWR VPWR sky130_fd_sc_hd__decap_3
Xclkbuf_3_1__f_clk clkbuf_0_clk/X VGND VGND VPWR VPWR clkbuf_leaf_1_clk/A sky130_fd_sc_hd__clkbuf_16
XFILLER_113_405 VGND VGND VPWR VPWR sky130_fd_sc_hd__decap_3
XPHY_EDGE_ROW_28_Right_28 VGND VGND VPWR VPWR sky130_fd_sc_hd__decap_3
XFILLER_99_617 VGND VGND VPWR VPWR sky130_fd_sc_hd__decap_3
XFILLER_113_438 VGND VGND VPWR VPWR sky130_fd_sc_hd__decap_3
XFILLER_113_449 VGND VGND VPWR VPWR sky130_fd_sc_hd__decap_3
XFILLER_97_83 VGND VGND VPWR VPWR sky130_fd_sc_hd__decap_3
XFILLER_67_514 VGND VGND VPWR VPWR sky130_fd_sc_hd__decap_3
XFILLER_79_363 VGND VGND VPWR VPWR sky130_fd_sc_hd__fill_2
XFILLER_67_547 VGND VGND VPWR VPWR sky130_fd_sc_hd__decap_3
XFILLER_79_396 VGND VGND VPWR VPWR sky130_fd_sc_hd__decap_3
XFILLER_94_333 VGND VGND VPWR VPWR sky130_fd_sc_hd__decap_3
XFILLER_35_422 VGND VGND VPWR VPWR sky130_fd_sc_hd__decap_3
XFILLER_75_591 VGND VGND VPWR VPWR sky130_fd_sc_hd__decap_3
XPHY_EDGE_ROW_37_Right_37 VGND VGND VPWR VPWR sky130_fd_sc_hd__decap_3
XFILLER_35_444 VGND VGND VPWR VPWR sky130_fd_sc_hd__decap_3
X_6840_ _7351_/CLK _6840_/D VGND VGND VPWR VPWR _6840_/Q sky130_fd_sc_hd__dfxtp_2
XFILLER_23_617 VGND VGND VPWR VPWR sky130_fd_sc_hd__decap_3
XFILLER_35_477 VGND VGND VPWR VPWR sky130_fd_sc_hd__decap_3
XFILLER_90_583 VGND VGND VPWR VPWR sky130_fd_sc_hd__fill_2
X_6771_ _6967_/CLK _6771_/D VGND VGND VPWR VPWR _6771_/Q sky130_fd_sc_hd__dfxtp_2
XFILLER_22_138 VGND VGND VPWR VPWR sky130_fd_sc_hd__fill_2
XFILLER_50_447 VGND VGND VPWR VPWR sky130_fd_sc_hd__fill_2
X_3983_ _7349_/Q _4524_/A0 _3994_/S VGND VGND VPWR VPWR _3983_/X sky130_fd_sc_hd__mux2_2
XTAP_TAPCELL_ROW_33_645 VGND VPWR sky130_fd_sc_hd__tapvpwrvgnd_1
XFILLER_15_190 VGND VGND VPWR VPWR sky130_fd_sc_hd__decap_3
XFILLER_50_469 VGND VGND VPWR VPWR sky130_fd_sc_hd__decap_3
XTAP_TAPCELL_ROW_61_987 VGND VPWR sky130_fd_sc_hd__tapvpwrvgnd_1
XFILLER_30_171 VGND VGND VPWR VPWR sky130_fd_sc_hd__decap_3
X_5653_ _5664_/B VGND VGND VPWR VPWR _5653_/Y sky130_fd_sc_hd__inv_2
X_4604_ _5634_/B VGND VGND VPWR VPWR _4671_/B sky130_fd_sc_hd__inv_2
XPHY_EDGE_ROW_46_Right_46 VGND VGND VPWR VPWR sky130_fd_sc_hd__decap_3
X_7323_ clkload2/A _7323_/D _6603_/Y VGND VGND VPWR VPWR _7323_/Q sky130_fd_sc_hd__dfrtp_2
XFILLER_116_243 VGND VGND VPWR VPWR sky130_fd_sc_hd__fill_1
XFILLER_116_265 VGND VGND VPWR VPWR sky130_fd_sc_hd__decap_3
XFILLER_116_298 VGND VGND VPWR VPWR sky130_fd_sc_hd__decap_3
XFILLER_89_105 VGND VGND VPWR VPWR sky130_fd_sc_hd__decap_3
XFILLER_89_116 VGND VGND VPWR VPWR sky130_fd_sc_hd__decap_3
X_7254_ clkload4/A _7254_/D _6534_/Y VGND VGND VPWR VPWR _7254_/Q sky130_fd_sc_hd__dfrtp_2
X_4466_ _4466_/A _5650_/A VGND VGND VPWR VPWR _4466_/Y sky130_fd_sc_hd__nand2_2
X_7185_ clkload3/A _7185_/D _6465_/Y VGND VGND VPWR VPWR _7185_/Q sky130_fd_sc_hd__dfrtp_2
X_4397_ _4397_/A _4648_/A VGND VGND VPWR VPWR _4447_/A sky130_fd_sc_hd__nor2_2
X_3417_ _3449_/B _3421_/C _3417_/C VGND VGND VPWR VPWR _3417_/X sky130_fd_sc_hd__and3_2
XFILLER_58_525 VGND VGND VPWR VPWR sky130_fd_sc_hd__decap_3
XFILLER_97_160 VGND VGND VPWR VPWR sky130_fd_sc_hd__decap_3
X_3348_ _3371_/A _3365_/A _3561_/A VGND VGND VPWR VPWR _5130_/A sky130_fd_sc_hd__a21oi_2
XTAP_TAPCELL_ROW_5_315 VGND VPWR sky130_fd_sc_hd__tapvpwrvgnd_1
XFILLER_58_536 VGND VGND VPWR VPWR sky130_fd_sc_hd__decap_3
XFILLER_85_322 VGND VGND VPWR VPWR sky130_fd_sc_hd__decap_3
Xhold1001 _7194_/Q VGND VGND VPWR VPWR _5272_/A0 sky130_fd_sc_hd__dlygate4sd3_1
Xhold1012 _7273_/Q VGND VGND VPWR VPWR _4807_/A0 sky130_fd_sc_hd__dlygate4sd3_1
Xhold1023 _7186_/Q VGND VGND VPWR VPWR _5286_/A0 sky130_fd_sc_hd__dlygate4sd3_1
XFILLER_73_517 VGND VGND VPWR VPWR sky130_fd_sc_hd__decap_3
Xhold1034 _7050_/Q VGND VGND VPWR VPWR _5567_/A1 sky130_fd_sc_hd__dlygate4sd3_1
Xhold1045 _7325_/Q VGND VGND VPWR VPWR _4509_/A1 sky130_fd_sc_hd__dlygate4sd3_1
Xhold1056 _7386_/Q VGND VGND VPWR VPWR _3860_/A0 sky130_fd_sc_hd__dlygate4sd3_1
Xhold1067 _7401_/Q VGND VGND VPWR VPWR _3702_/A1 sky130_fd_sc_hd__dlygate4sd3_1
XPHY_EDGE_ROW_55_Right_55 VGND VGND VPWR VPWR sky130_fd_sc_hd__decap_3
XFILLER_26_24 VGND VGND VPWR VPWR sky130_fd_sc_hd__decap_3
XFILLER_38_271 VGND VGND VPWR VPWR sky130_fd_sc_hd__decap_3
XFILLER_45_219 VGND VGND VPWR VPWR sky130_fd_sc_hd__decap_3
XFILLER_85_399 VGND VGND VPWR VPWR sky130_fd_sc_hd__decap_3
Xhold1078 _7389_/Q VGND VGND VPWR VPWR _3822_/A1 sky130_fd_sc_hd__dlygate4sd3_1
Xhold1089 _7190_/Q VGND VGND VPWR VPWR _5280_/A0 sky130_fd_sc_hd__dlygate4sd3_1
X_5018_ _5018_/A _5018_/B VGND VGND VPWR VPWR _5018_/Y sky130_fd_sc_hd__nor2_2
XFILLER_26_35 VGND VGND VPWR VPWR sky130_fd_sc_hd__decap_3
XFILLER_26_433 VGND VGND VPWR VPWR sky130_fd_sc_hd__decap_3
XFILLER_26_46 VGND VGND VPWR VPWR sky130_fd_sc_hd__decap_3
XFILLER_38_293 VGND VGND VPWR VPWR sky130_fd_sc_hd__decap_3
XFILLER_81_550 VGND VGND VPWR VPWR sky130_fd_sc_hd__decap_3
XFILLER_26_488 VGND VGND VPWR VPWR sky130_fd_sc_hd__decap_3
XFILLER_26_79 VGND VGND VPWR VPWR sky130_fd_sc_hd__decap_3
XFILLER_81_561 VGND VGND VPWR VPWR sky130_fd_sc_hd__decap_3
XFILLER_13_116 VGND VGND VPWR VPWR sky130_fd_sc_hd__decap_3
XFILLER_41_425 VGND VGND VPWR VPWR sky130_fd_sc_hd__decap_3
XFILLER_41_447 VGND VGND VPWR VPWR sky130_fd_sc_hd__fill_1
XFILLER_53_296 VGND VGND VPWR VPWR sky130_fd_sc_hd__decap_3
XFILLER_81_594 VGND VGND VPWR VPWR sky130_fd_sc_hd__decap_3
X_6969_ _6976_/CLK _6969_/D VGND VGND VPWR VPWR _6969_/Q sky130_fd_sc_hd__dfxtp_2
XFILLER_41_469 VGND VGND VPWR VPWR sky130_fd_sc_hd__decap_3
XFILLER_21_160 VGND VGND VPWR VPWR sky130_fd_sc_hd__decap_3
XFILLER_42_56 VGND VGND VPWR VPWR sky130_fd_sc_hd__fill_1
XTAP_TAPCELL_ROW_101_1467 VGND VPWR sky130_fd_sc_hd__tapvpwrvgnd_1
XPHY_EDGE_ROW_64_Right_64 VGND VGND VPWR VPWR sky130_fd_sc_hd__decap_3
XFILLER_21_193 VGND VGND VPWR VPWR sky130_fd_sc_hd__decap_3
XFILLER_5_326 VGND VGND VPWR VPWR sky130_fd_sc_hd__decap_3
XFILLER_5_337 VGND VGND VPWR VPWR sky130_fd_sc_hd__decap_3
XFILLER_107_243 VGND VGND VPWR VPWR sky130_fd_sc_hd__decap_3
XFILLER_89_650 VGND VGND VPWR VPWR sky130_fd_sc_hd__decap_3
Xhold890 _7105_/Q VGND VGND VPWR VPWR _7105_/D sky130_fd_sc_hd__dlygate4sd3_1
XFILLER_107_60 VGND VGND VPWR VPWR sky130_fd_sc_hd__decap_3
XFILLER_107_93 VGND VGND VPWR VPWR sky130_fd_sc_hd__decap_3
XFILLER_110_419 VGND VGND VPWR VPWR sky130_fd_sc_hd__fill_1
XFILLER_1_598 VGND VGND VPWR VPWR sky130_fd_sc_hd__fill_1
XFILLER_49_547 VGND VGND VPWR VPWR sky130_fd_sc_hd__fill_2
XFILLER_67_64 VGND VGND VPWR VPWR sky130_fd_sc_hd__decap_3
XFILLER_76_333 VGND VGND VPWR VPWR sky130_fd_sc_hd__decap_3
XTAP_TAPCELL_ROW_112_1596 VGND VPWR sky130_fd_sc_hd__tapvpwrvgnd_1
XPHY_EDGE_ROW_73_Right_73 VGND VGND VPWR VPWR sky130_fd_sc_hd__decap_3
XFILLER_49_569 VGND VGND VPWR VPWR sky130_fd_sc_hd__decap_3
XFILLER_76_377 VGND VGND VPWR VPWR sky130_fd_sc_hd__decap_3
XFILLER_91_303 VGND VGND VPWR VPWR sky130_fd_sc_hd__decap_3
XFILLER_29_260 VGND VGND VPWR VPWR sky130_fd_sc_hd__decap_3
XFILLER_64_528 VGND VGND VPWR VPWR sky130_fd_sc_hd__decap_3
XFILLER_64_539 VGND VGND VPWR VPWR sky130_fd_sc_hd__decap_3
XFILLER_17_455 VGND VGND VPWR VPWR sky130_fd_sc_hd__decap_3
XFILLER_91_358 VGND VGND VPWR VPWR sky130_fd_sc_hd__decap_3
XFILLER_72_572 VGND VGND VPWR VPWR sky130_fd_sc_hd__fill_1
XFILLER_83_63 VGND VGND VPWR VPWR sky130_fd_sc_hd__fill_1
XFILLER_83_74 VGND VGND VPWR VPWR sky130_fd_sc_hd__decap_3
XTAP_TAPCELL_ROW_67_1053 VGND VPWR sky130_fd_sc_hd__tapvpwrvgnd_1
XPHY_EDGE_ROW_17_Left_134 VGND VGND VPWR VPWR sky130_fd_sc_hd__decap_3
XFILLER_32_469 VGND VGND VPWR VPWR sky130_fd_sc_hd__fill_1
XPHY_EDGE_ROW_82_Right_82 VGND VGND VPWR VPWR sky130_fd_sc_hd__decap_3
XFILLER_40_480 VGND VGND VPWR VPWR sky130_fd_sc_hd__decap_3
XTAP_TAPCELL_ROW_30_615 VGND VPWR sky130_fd_sc_hd__tapvpwrvgnd_1
XFILLER_8_153 VGND VGND VPWR VPWR sky130_fd_sc_hd__decap_3
XFILLER_8_186 VGND VGND VPWR VPWR sky130_fd_sc_hd__decap_3
XFILLER_8_197 VGND VGND VPWR VPWR sky130_fd_sc_hd__decap_3
XTAP_TAPCELL_ROW_10_372 VGND VPWR sky130_fd_sc_hd__tapvpwrvgnd_1
XFILLER_113_213 VGND VGND VPWR VPWR sky130_fd_sc_hd__decap_3
X_4320_ _7066_/Q _4265_/B _4460_/A VGND VGND VPWR VPWR _4362_/B sky130_fd_sc_hd__o21a_2
XTAP_TAPCELL_ROW_78_1193 VGND VPWR sky130_fd_sc_hd__tapvpwrvgnd_1
XTAP_TAPCELL_ROW_78_1182 VGND VPWR sky130_fd_sc_hd__tapvpwrvgnd_1
XFILLER_99_414 VGND VGND VPWR VPWR sky130_fd_sc_hd__decap_3
X_4251_ _7016_/Q _3358_/X _4351_/B1 _7133_/Q _4250_/X VGND VGND VPWR VPWR _4251_/X
+ sky130_fd_sc_hd__a221o_2
XPHY_EDGE_ROW_26_Left_143 VGND VGND VPWR VPWR sky130_fd_sc_hd__decap_3
XFILLER_99_458 VGND VGND VPWR VPWR sky130_fd_sc_hd__decap_3
XFILLER_99_447 VGND VGND VPWR VPWR sky130_fd_sc_hd__fill_1
XFILLER_113_268 VGND VGND VPWR VPWR sky130_fd_sc_hd__decap_3
XPHY_EDGE_ROW_91_Right_91 VGND VGND VPWR VPWR sky130_fd_sc_hd__decap_3
XFILLER_67_322 VGND VGND VPWR VPWR sky130_fd_sc_hd__decap_3
XFILLER_95_620 VGND VGND VPWR VPWR sky130_fd_sc_hd__decap_3
X_4182_ _7136_/Q _4195_/A2 _4180_/X _4181_/X VGND VGND VPWR VPWR _4182_/X sky130_fd_sc_hd__a211o_2
XFILLER_67_355 VGND VGND VPWR VPWR sky130_fd_sc_hd__decap_3
XFILLER_94_141 VGND VGND VPWR VPWR sky130_fd_sc_hd__decap_3
XFILLER_94_152 VGND VGND VPWR VPWR sky130_fd_sc_hd__decap_3
XTAP_TAPCELL_ROW_38_704 VGND VPWR sky130_fd_sc_hd__tapvpwrvgnd_1
XFILLER_103_18 VGND VGND VPWR VPWR sky130_fd_sc_hd__decap_3
XFILLER_82_358 VGND VGND VPWR VPWR sky130_fd_sc_hd__decap_3
XFILLER_23_414 VGND VGND VPWR VPWR sky130_fd_sc_hd__decap_3
XFILLER_35_263 VGND VGND VPWR VPWR sky130_fd_sc_hd__fill_1
XFILLER_50_200 VGND VGND VPWR VPWR sky130_fd_sc_hd__decap_3
XFILLER_63_561 VGND VGND VPWR VPWR sky130_fd_sc_hd__decap_3
XPHY_EDGE_ROW_35_Left_152 VGND VGND VPWR VPWR sky130_fd_sc_hd__decap_3
XFILLER_35_296 VGND VGND VPWR VPWR sky130_fd_sc_hd__decap_3
XFILLER_90_380 VGND VGND VPWR VPWR sky130_fd_sc_hd__decap_3
X_6823_ _6929_/CLK _6823_/D VGND VGND VPWR VPWR _6823_/Q sky130_fd_sc_hd__dfxtp_2
XTAP_TAPCELL_ROW_18_472 VGND VPWR sky130_fd_sc_hd__tapvpwrvgnd_1
XFILLER_23_458 VGND VGND VPWR VPWR sky130_fd_sc_hd__fill_1
XFILLER_50_244 VGND VGND VPWR VPWR sky130_fd_sc_hd__decap_3
X_6754_ _6965_/CLK _6754_/D VGND VGND VPWR VPWR _6754_/Q sky130_fd_sc_hd__dfxtp_2
X_3966_ _7357_/Q _4509_/A1 _4471_/S VGND VGND VPWR VPWR _7357_/D sky130_fd_sc_hd__mux2_2
XFILLER_50_288 VGND VGND VPWR VPWR sky130_fd_sc_hd__decap_3
X_6685_ _6686_/A VGND VGND VPWR VPWR _6685_/Y sky130_fd_sc_hd__inv_2
X_5705_ hold911/X _5729_/S _4270_/Y VGND VGND VPWR VPWR _6702_/D sky130_fd_sc_hd__a21bo_2
XFILLER_109_508 VGND VGND VPWR VPWR sky130_fd_sc_hd__decap_3
XFILLER_12_15 VGND VGND VPWR VPWR sky130_fd_sc_hd__decap_3
XFILLER_31_491 VGND VGND VPWR VPWR sky130_fd_sc_hd__decap_3
X_3897_ hold996/X _5104_/A _3896_/Y VGND VGND VPWR VPWR _7382_/D sky130_fd_sc_hd__a21bo_2
XFILLER_12_59 VGND VGND VPWR VPWR sky130_fd_sc_hd__decap_3
X_5567_ _5567_/A1 _4960_/A _4870_/Y VGND VGND VPWR VPWR _7050_/D sky130_fd_sc_hd__a21o_2
X_7306_ _7307_/CLK _7306_/D _6586_/Y VGND VGND VPWR VPWR _7306_/Q sky130_fd_sc_hd__dfrtp_2
XPHY_EDGE_ROW_44_Left_161 VGND VGND VPWR VPWR sky130_fd_sc_hd__decap_3
XFILLER_104_246 VGND VGND VPWR VPWR sky130_fd_sc_hd__decap_3
XFILLER_5_9 VGND VGND VPWR VPWR sky130_fd_sc_hd__fill_1
X_7237_ _7361_/CLK _7237_/D _6517_/Y VGND VGND VPWR VPWR _7237_/Q sky130_fd_sc_hd__dfrtp_2
X_4449_ _4403_/A _4411_/B _4448_/X VGND VGND VPWR VPWR _4761_/C sky130_fd_sc_hd__a21oi_2
XFILLER_58_300 VGND VGND VPWR VPWR sky130_fd_sc_hd__decap_3
X_7168_ _7396_/CLK _7168_/D _6448_/Y VGND VGND VPWR VPWR _7168_/Q sky130_fd_sc_hd__dfrtp_2
XFILLER_98_480 VGND VGND VPWR VPWR sky130_fd_sc_hd__decap_3
XFILLER_46_506 VGND VGND VPWR VPWR sky130_fd_sc_hd__decap_3
XFILLER_58_344 VGND VGND VPWR VPWR sky130_fd_sc_hd__decap_3
XFILLER_85_130 VGND VGND VPWR VPWR sky130_fd_sc_hd__decap_3
X_7099_ clkload5/A _7099_/D _6379_/Y VGND VGND VPWR VPWR _7099_/Q sky130_fd_sc_hd__dfrtp_2
XFILLER_100_474 VGND VGND VPWR VPWR sky130_fd_sc_hd__fill_2
XFILLER_58_399 VGND VGND VPWR VPWR sky130_fd_sc_hd__decap_3
XFILLER_73_325 VGND VGND VPWR VPWR sky130_fd_sc_hd__decap_3
XFILLER_85_163 VGND VGND VPWR VPWR sky130_fd_sc_hd__decap_3
XFILLER_85_185 VGND VGND VPWR VPWR sky130_fd_sc_hd__decap_3
XFILLER_73_358 VGND VGND VPWR VPWR sky130_fd_sc_hd__decap_3
XPHY_EDGE_ROW_53_Left_170 VGND VGND VPWR VPWR sky130_fd_sc_hd__decap_3
XFILLER_14_414 VGND VGND VPWR VPWR sky130_fd_sc_hd__decap_3
XFILLER_26_263 VGND VGND VPWR VPWR sky130_fd_sc_hd__decap_3
XFILLER_14_436 VGND VGND VPWR VPWR sky130_fd_sc_hd__fill_2
XFILLER_53_33 VGND VGND VPWR VPWR sky130_fd_sc_hd__fill_1
XFILLER_41_244 VGND VGND VPWR VPWR sky130_fd_sc_hd__decap_3
XFILLER_53_66 VGND VGND VPWR VPWR sky130_fd_sc_hd__decap_3
XFILLER_41_277 VGND VGND VPWR VPWR sky130_fd_sc_hd__decap_3
XFILLER_41_299 VGND VGND VPWR VPWR sky130_fd_sc_hd__decap_3
XFILLER_53_99 VGND VGND VPWR VPWR sky130_fd_sc_hd__decap_3
XFILLER_5_134 VGND VGND VPWR VPWR sky130_fd_sc_hd__decap_3
XFILLER_108_563 VGND VGND VPWR VPWR sky130_fd_sc_hd__decap_3
XFILLER_108_585 VGND VGND VPWR VPWR sky130_fd_sc_hd__decap_3
XFILLER_5_167 VGND VGND VPWR VPWR sky130_fd_sc_hd__fill_1
XFILLER_5_178 VGND VGND VPWR VPWR sky130_fd_sc_hd__decap_3
XTAP_TAPCELL_ROW_114_1625 VGND VPWR sky130_fd_sc_hd__tapvpwrvgnd_1
XTAP_TAPCELL_ROW_114_1614 VGND VPWR sky130_fd_sc_hd__tapvpwrvgnd_1
XFILLER_69_609 VGND VGND VPWR VPWR sky130_fd_sc_hd__decap_3
XFILLER_110_205 VGND VGND VPWR VPWR sky130_fd_sc_hd__decap_3
XFILLER_1_340 VGND VGND VPWR VPWR sky130_fd_sc_hd__decap_3
XFILLER_38_9 VGND VGND VPWR VPWR sky130_fd_sc_hd__decap_3
XFILLER_68_119 VGND VGND VPWR VPWR sky130_fd_sc_hd__decap_3
XFILLER_78_63 VGND VGND VPWR VPWR sky130_fd_sc_hd__decap_3
XFILLER_78_85 VGND VGND VPWR VPWR sky130_fd_sc_hd__decap_3
XFILLER_96_406 VGND VGND VPWR VPWR sky130_fd_sc_hd__decap_3
XFILLER_49_333 VGND VGND VPWR VPWR sky130_fd_sc_hd__decap_3
XFILLER_89_491 VGND VGND VPWR VPWR sky130_fd_sc_hd__decap_3
XFILLER_103_290 VGND VGND VPWR VPWR sky130_fd_sc_hd__decap_3
XFILLER_49_355 VGND VGND VPWR VPWR sky130_fd_sc_hd__decap_3
XFILLER_76_130 VGND VGND VPWR VPWR sky130_fd_sc_hd__decap_3
XFILLER_76_141 VGND VGND VPWR VPWR sky130_fd_sc_hd__decap_3
XFILLER_94_62 VGND VGND VPWR VPWR sky130_fd_sc_hd__decap_3
XFILLER_91_122 VGND VGND VPWR VPWR sky130_fd_sc_hd__fill_1
XFILLER_92_645 VGND VGND VPWR VPWR sky130_fd_sc_hd__decap_3
XFILLER_45_561 VGND VGND VPWR VPWR sky130_fd_sc_hd__fill_2
XFILLER_91_177 VGND VGND VPWR VPWR sky130_fd_sc_hd__decap_3
XFILLER_17_274 VGND VGND VPWR VPWR sky130_fd_sc_hd__decap_3
XFILLER_32_222 VGND VGND VPWR VPWR sky130_fd_sc_hd__decap_3
XFILLER_32_244 VGND VGND VPWR VPWR sky130_fd_sc_hd__decap_3
XFILLER_60_542 VGND VGND VPWR VPWR sky130_fd_sc_hd__decap_3
X_3820_ _6927_/Q _3859_/A2 _3925_/A2 _6701_/Q VGND VGND VPWR VPWR _3820_/X sky130_fd_sc_hd__a22o_2
XTAP_TAPCELL_ROW_43_762 VGND VPWR sky130_fd_sc_hd__tapvpwrvgnd_1
XTAP_TAPCELL_ROW_15_431 VGND VPWR sky130_fd_sc_hd__tapvpwrvgnd_1
X_3751_ _6935_/Q _3828_/A2 _3858_/B1 _6887_/Q VGND VGND VPWR VPWR _3751_/X sky130_fd_sc_hd__a22o_2
XTAP_TAPCELL_ROW_43_773 VGND VPWR sky130_fd_sc_hd__tapvpwrvgnd_1
XFILLER_71_3 VGND VGND VPWR VPWR sky130_fd_sc_hd__decap_3
X_6470_ _6562_/A VGND VGND VPWR VPWR _6470_/Y sky130_fd_sc_hd__inv_2
X_3682_ _3682_/A _3682_/B VGND VGND VPWR VPWR _3682_/Y sky130_fd_sc_hd__nand2_2
X_5421_ _7123_/Q _5135_/X _5429_/S VGND VGND VPWR VPWR _7123_/D sky130_fd_sc_hd__mux2_2
XFILLER_114_500 VGND VGND VPWR VPWR sky130_fd_sc_hd__fill_1
X_5352_ _5352_/A0 _5135_/X _5360_/S VGND VGND VPWR VPWR _7155_/D sky130_fd_sc_hd__mux2_2
XFILLER_114_533 VGND VGND VPWR VPWR sky130_fd_sc_hd__decap_3
XFILLER_114_544 VGND VGND VPWR VPWR sky130_fd_sc_hd__fill_2
X_4303_ _7320_/Q _3399_/A _4348_/B1 _7128_/Q _4302_/X VGND VGND VPWR VPWR _4303_/X
+ sky130_fd_sc_hd__a221o_2
XFILLER_4_60 VGND VGND VPWR VPWR sky130_fd_sc_hd__decap_3
XFILLER_59_119 VGND VGND VPWR VPWR sky130_fd_sc_hd__decap_3
XFILLER_87_428 VGND VGND VPWR VPWR sky130_fd_sc_hd__decap_3
X_7022_ _7338_/CLK _7022_/D _6302_/Y VGND VGND VPWR VPWR _7022_/Q sky130_fd_sc_hd__dfrtp_2
X_5283_ _3600_/A _4765_/A _5238_/X hold972/X VGND VGND VPWR VPWR _7188_/D sky130_fd_sc_hd__a22o_2
XFILLER_99_255 VGND VGND VPWR VPWR sky130_fd_sc_hd__decap_3
XFILLER_101_216 VGND VGND VPWR VPWR sky130_fd_sc_hd__decap_3
XFILLER_4_82 VGND VGND VPWR VPWR sky130_fd_sc_hd__fill_2
X_4234_ _7355_/Q _4338_/B1 _4233_/X _3556_/A VGND VGND VPWR VPWR _4234_/X sky130_fd_sc_hd__a211o_2
XFILLER_99_299 VGND VGND VPWR VPWR sky130_fd_sc_hd__decap_3
XFILLER_68_675 VGND VGND VPWR VPWR sky130_fd_sc_hd__fill_1
X_4165_ _7018_/Q _4418_/A2 _4195_/A2 _7137_/Q _4164_/X VGND VGND VPWR VPWR _4165_/X
+ sky130_fd_sc_hd__a221o_2
XFILLER_82_111 VGND VGND VPWR VPWR sky130_fd_sc_hd__fill_2
XFILLER_83_634 VGND VGND VPWR VPWR sky130_fd_sc_hd__decap_3
XFILLER_95_461 VGND VGND VPWR VPWR sky130_fd_sc_hd__decap_3
XFILLER_95_494 VGND VGND VPWR VPWR sky130_fd_sc_hd__decap_3
XFILLER_55_358 VGND VGND VPWR VPWR sky130_fd_sc_hd__decap_3
XFILLER_82_122 VGND VGND VPWR VPWR sky130_fd_sc_hd__fill_1
XFILLER_82_144 VGND VGND VPWR VPWR sky130_fd_sc_hd__decap_3
X_4096_ _4096_/A _4096_/B VGND VGND VPWR VPWR _4633_/A sky130_fd_sc_hd__nand2_2
XFILLER_70_306 VGND VGND VPWR VPWR sky130_fd_sc_hd__fill_2
XFILLER_70_317 VGND VGND VPWR VPWR sky130_fd_sc_hd__decap_3
XFILLER_82_177 VGND VGND VPWR VPWR sky130_fd_sc_hd__decap_3
XFILLER_23_222 VGND VGND VPWR VPWR sky130_fd_sc_hd__fill_2
XFILLER_63_391 VGND VGND VPWR VPWR sky130_fd_sc_hd__fill_1
XFILLER_51_542 VGND VGND VPWR VPWR sky130_fd_sc_hd__decap_3
Xplace391 _5633_/B VGND VGND VPWR VPWR _5605_/B sky130_fd_sc_hd__buf_2
Xplace380 _4466_/A VGND VGND VPWR VPWR _5104_/A sky130_fd_sc_hd__buf_2
X_6806_ _6966_/CLK _6806_/D VGND VGND VPWR VPWR _6806_/Q sky130_fd_sc_hd__dfxtp_2
XFILLER_11_417 VGND VGND VPWR VPWR sky130_fd_sc_hd__fill_1
XFILLER_23_266 VGND VGND VPWR VPWR sky130_fd_sc_hd__decap_3
XFILLER_23_36 VGND VGND VPWR VPWR sky130_fd_sc_hd__decap_3
X_4998_ _4998_/A0 _4997_/X _5028_/S VGND VGND VPWR VPWR _7262_/D sky130_fd_sc_hd__mux2_2
XFILLER_23_47 VGND VGND VPWR VPWR sky130_fd_sc_hd__decap_3
XFILLER_23_69 VGND VGND VPWR VPWR sky130_fd_sc_hd__decap_3
X_6737_ _6965_/CLK _6737_/D VGND VGND VPWR VPWR _6737_/Q sky130_fd_sc_hd__dfxtp_2
X_3949_ _7365_/Q _4493_/A0 _3958_/S VGND VGND VPWR VPWR _7365_/D sky130_fd_sc_hd__mux2_2
XFILLER_109_316 VGND VGND VPWR VPWR sky130_fd_sc_hd__decap_3
X_6668_ _6670_/A VGND VGND VPWR VPWR _6668_/Y sky130_fd_sc_hd__inv_2
XFILLER_109_349 VGND VGND VPWR VPWR sky130_fd_sc_hd__decap_3
X_6599_ _6599_/A VGND VGND VPWR VPWR _6599_/Y sky130_fd_sc_hd__inv_2
X_5619_ _5619_/A _5633_/B VGND VGND VPWR VPWR _7018_/D sky130_fd_sc_hd__or2_2
XFILLER_105_511 VGND VGND VPWR VPWR sky130_fd_sc_hd__fill_1
XFILLER_3_6 VGND VGND VPWR VPWR sky130_fd_sc_hd__decap_3
XFILLER_48_22 VGND VGND VPWR VPWR sky130_fd_sc_hd__decap_3
XFILLER_78_428 VGND VGND VPWR VPWR sky130_fd_sc_hd__decap_3
XFILLER_48_44 VGND VGND VPWR VPWR sky130_fd_sc_hd__fill_2
XFILLER_58_141 VGND VGND VPWR VPWR sky130_fd_sc_hd__decap_3
XFILLER_59_642 VGND VGND VPWR VPWR sky130_fd_sc_hd__decap_3
XFILLER_58_174 VGND VGND VPWR VPWR sky130_fd_sc_hd__decap_3
XFILLER_74_601 VGND VGND VPWR VPWR sky130_fd_sc_hd__decap_3
XFILLER_74_623 VGND VGND VPWR VPWR sky130_fd_sc_hd__fill_2
XFILLER_86_483 VGND VGND VPWR VPWR sky130_fd_sc_hd__fill_2
XFILLER_0_29 VGND VGND VPWR VPWR sky130_fd_sc_hd__decap_3
XFILLER_104_50 VGND VGND VPWR VPWR sky130_fd_sc_hd__decap_3
XFILLER_73_111 VGND VGND VPWR VPWR sky130_fd_sc_hd__fill_1
XFILLER_74_645 VGND VGND VPWR VPWR sky130_fd_sc_hd__fill_2
XFILLER_104_83 VGND VGND VPWR VPWR sky130_fd_sc_hd__fill_1
XFILLER_14_200 VGND VGND VPWR VPWR sky130_fd_sc_hd__decap_3
XFILLER_54_391 VGND VGND VPWR VPWR sky130_fd_sc_hd__decap_3
XTAP_TAPCELL_ROW_64_1023 VGND VPWR sky130_fd_sc_hd__tapvpwrvgnd_1
XTAP_TAPCELL_ROW_12_401 VGND VPWR sky130_fd_sc_hd__tapvpwrvgnd_1
XFILLER_14_299 VGND VGND VPWR VPWR sky130_fd_sc_hd__decap_3
XFILLER_80_53 VGND VGND VPWR VPWR sky130_fd_sc_hd__decap_3
XFILLER_80_75 VGND VGND VPWR VPWR sky130_fd_sc_hd__decap_3
Xfanout70 _6523_/A VGND VGND VPWR VPWR _6585_/A sky130_fd_sc_hd__buf_1
XTAP_TAPCELL_ROW_40_732 VGND VPWR sky130_fd_sc_hd__tapvpwrvgnd_1
XFILLER_6_421 VGND VGND VPWR VPWR sky130_fd_sc_hd__fill_2
XFILLER_6_454 VGND VGND VPWR VPWR sky130_fd_sc_hd__fill_2
XFILLER_108_360 VGND VGND VPWR VPWR sky130_fd_sc_hd__decap_3
XFILLER_108_371 VGND VGND VPWR VPWR sky130_fd_sc_hd__decap_3
XFILLER_89_40 VGND VGND VPWR VPWR sky130_fd_sc_hd__decap_3
XPHY_EDGE_ROW_108_Right_108 VGND VGND VPWR VPWR sky130_fd_sc_hd__decap_3
XFILLER_89_84 VGND VGND VPWR VPWR sky130_fd_sc_hd__decap_3
XTAP_TAPCELL_ROW_75_1152 VGND VPWR sky130_fd_sc_hd__tapvpwrvgnd_1
XFILLER_69_417 VGND VGND VPWR VPWR sky130_fd_sc_hd__decap_3
XFILLER_96_203 VGND VGND VPWR VPWR sky130_fd_sc_hd__decap_3
XFILLER_2_682 VGND VGND VPWR VPWR sky130_fd_sc_hd__fill_2
XFILLER_36_6 VGND VGND VPWR VPWR sky130_fd_sc_hd__decap_3
XFILLER_1_181 VGND VGND VPWR VPWR sky130_fd_sc_hd__decap_3
XFILLER_37_314 VGND VGND VPWR VPWR sky130_fd_sc_hd__decap_3
XFILLER_49_152 VGND VGND VPWR VPWR sky130_fd_sc_hd__decap_3
XFILLER_77_472 VGND VGND VPWR VPWR sky130_fd_sc_hd__decap_3
XFILLER_37_325 VGND VGND VPWR VPWR sky130_fd_sc_hd__decap_3
XFILLER_64_111 VGND VGND VPWR VPWR sky130_fd_sc_hd__decap_3
XFILLER_65_634 VGND VGND VPWR VPWR sky130_fd_sc_hd__decap_3
XFILLER_65_667 VGND VGND VPWR VPWR sky130_fd_sc_hd__decap_3
XTAP_TAPCELL_ROW_48_832 VGND VPWR sky130_fd_sc_hd__tapvpwrvgnd_1
XFILLER_64_166 VGND VGND VPWR VPWR sky130_fd_sc_hd__decap_3
XFILLER_65_689 VGND VGND VPWR VPWR sky130_fd_sc_hd__decap_3
XFILLER_80_604 VGND VGND VPWR VPWR sky130_fd_sc_hd__fill_2
XFILLER_92_464 VGND VGND VPWR VPWR sky130_fd_sc_hd__decap_3
XFILLER_92_486 VGND VGND VPWR VPWR sky130_fd_sc_hd__decap_3
XFILLER_52_339 VGND VGND VPWR VPWR sky130_fd_sc_hd__decap_3
XFILLER_64_188 VGND VGND VPWR VPWR sky130_fd_sc_hd__decap_3
XFILLER_80_648 VGND VGND VPWR VPWR sky130_fd_sc_hd__fill_2
X_4921_ _4968_/A _4383_/C _4201_/X VGND VGND VPWR VPWR _4937_/B sky130_fd_sc_hd__a21bo_2
XTAP_TAPCELL_ROW_86_1281 VGND VPWR sky130_fd_sc_hd__tapvpwrvgnd_1
X_4852_ _4852_/A _5057_/A VGND VGND VPWR VPWR _5101_/A sky130_fd_sc_hd__and2_2
XFILLER_33_597 VGND VGND VPWR VPWR sky130_fd_sc_hd__fill_2
XFILLER_60_361 VGND VGND VPWR VPWR sky130_fd_sc_hd__decap_3
X_3803_ _6816_/Q _3882_/A2 _3912_/B1 _6821_/Q VGND VGND VPWR VPWR _3803_/X sky130_fd_sc_hd__a22o_2
XFILLER_20_236 VGND VGND VPWR VPWR sky130_fd_sc_hd__decap_3
XFILLER_60_394 VGND VGND VPWR VPWR sky130_fd_sc_hd__decap_3
X_4783_ _4646_/A _4646_/B _4827_/A VGND VGND VPWR VPWR _4829_/B sky130_fd_sc_hd__a21boi_2
X_6522_ _6522_/A VGND VGND VPWR VPWR _6522_/Y sky130_fd_sc_hd__inv_2
X_3734_ _3728_/Y _3730_/X _3732_/X _3733_/X VGND VGND VPWR VPWR _3734_/X sky130_fd_sc_hd__a22o_2
XFILLER_9_270 VGND VGND VPWR VPWR sky130_fd_sc_hd__fill_2
X_6453_ _6642_/A VGND VGND VPWR VPWR _6453_/Y sky130_fd_sc_hd__inv_2
X_3665_ _3665_/A _3665_/B VGND VGND VPWR VPWR _3665_/X sky130_fd_sc_hd__and2_4
XFILLER_9_281 VGND VGND VPWR VPWR sky130_fd_sc_hd__fill_2
X_5404_ _5404_/A0 _5040_/X _5429_/S VGND VGND VPWR VPWR _7131_/D sky130_fd_sc_hd__mux2_2
X_6384_ _6604_/A VGND VGND VPWR VPWR _6384_/Y sky130_fd_sc_hd__inv_2
X_3596_ _4295_/B _3607_/B VGND VGND VPWR VPWR _3598_/A sky130_fd_sc_hd__and2_2
XFILLER_114_352 VGND VGND VPWR VPWR sky130_fd_sc_hd__decap_3
XFILLER_87_203 VGND VGND VPWR VPWR sky130_fd_sc_hd__decap_3
XFILLER_102_514 VGND VGND VPWR VPWR sky130_fd_sc_hd__fill_2
XFILLER_102_525 VGND VGND VPWR VPWR sky130_fd_sc_hd__decap_3
XFILLER_114_385 VGND VGND VPWR VPWR sky130_fd_sc_hd__decap_3
X_5266_ _5266_/A0 _5011_/X _5274_/S VGND VGND VPWR VPWR _7197_/D sky130_fd_sc_hd__mux2_2
XFILLER_87_247 VGND VGND VPWR VPWR sky130_fd_sc_hd__fill_2
X_7005_ _7368_/CLK _7005_/D _6285_/Y VGND VGND VPWR VPWR _7005_/Q sky130_fd_sc_hd__dfrtp_2
X_4217_ _3757_/S _3469_/B _3449_/A _7015_/Q _3365_/A VGND VGND VPWR VPWR _4217_/X
+ sky130_fd_sc_hd__o2111a_2
XFILLER_18_58 VGND VGND VPWR VPWR sky130_fd_sc_hd__decap_3
XFILLER_28_336 VGND VGND VPWR VPWR sky130_fd_sc_hd__decap_3
XFILLER_56_645 VGND VGND VPWR VPWR sky130_fd_sc_hd__fill_2
XFILLER_68_494 VGND VGND VPWR VPWR sky130_fd_sc_hd__decap_3
X_4148_ _7074_/Q _4265_/B _4145_/X _4147_/X VGND VGND VPWR VPWR _4205_/B sky130_fd_sc_hd__o22a_2
XFILLER_43_317 VGND VGND VPWR VPWR sky130_fd_sc_hd__fill_1
XFILLER_55_144 VGND VGND VPWR VPWR sky130_fd_sc_hd__decap_3
XFILLER_55_166 VGND VGND VPWR VPWR sky130_fd_sc_hd__fill_2
XFILLER_56_689 VGND VGND VPWR VPWR sky130_fd_sc_hd__decap_3
X_4079_ _7403_/Q _4437_/B1 _4077_/X _4078_/X VGND VGND VPWR VPWR _4079_/X sky130_fd_sc_hd__a211o_2
XFILLER_36_380 VGND VGND VPWR VPWR sky130_fd_sc_hd__decap_3
XFILLER_70_114 VGND VGND VPWR VPWR sky130_fd_sc_hd__decap_3
XFILLER_70_125 VGND VGND VPWR VPWR sky130_fd_sc_hd__decap_3
XFILLER_83_497 VGND VGND VPWR VPWR sky130_fd_sc_hd__decap_3
XFILLER_34_24 VGND VGND VPWR VPWR sky130_fd_sc_hd__decap_3
XFILLER_70_147 VGND VGND VPWR VPWR sky130_fd_sc_hd__decap_3
XFILLER_70_169 VGND VGND VPWR VPWR sky130_fd_sc_hd__decap_3
XTAP_TAPCELL_ROW_26_559 VGND VPWR sky130_fd_sc_hd__tapvpwrvgnd_1
XFILLER_34_57 VGND VGND VPWR VPWR sky130_fd_sc_hd__decap_3
XFILLER_51_383 VGND VGND VPWR VPWR sky130_fd_sc_hd__decap_3
XFILLER_109_102 VGND VGND VPWR VPWR sky130_fd_sc_hd__decap_3
XFILLER_109_113 VGND VGND VPWR VPWR sky130_fd_sc_hd__decap_3
XFILLER_11_258 VGND VGND VPWR VPWR sky130_fd_sc_hd__fill_1
XFILLER_50_12 VGND VGND VPWR VPWR sky130_fd_sc_hd__decap_3
Xclkload1 clkload1/A VGND VGND VPWR VPWR clkload1/X sky130_fd_sc_hd__clkbuf_1
XFILLER_50_67 VGND VGND VPWR VPWR sky130_fd_sc_hd__decap_3
XFILLER_109_157 VGND VGND VPWR VPWR sky130_fd_sc_hd__decap_3
XFILLER_109_179 VGND VGND VPWR VPWR sky130_fd_sc_hd__decap_3
XFILLER_3_413 VGND VGND VPWR VPWR sky130_fd_sc_hd__fill_1
XFILLER_105_330 VGND VGND VPWR VPWR sky130_fd_sc_hd__decap_3
XFILLER_1_3 VGND VGND VPWR VPWR sky130_fd_sc_hd__fill_1
XFILLER_3_446 VGND VGND VPWR VPWR sky130_fd_sc_hd__fill_2
XFILLER_105_385 VGND VGND VPWR VPWR sky130_fd_sc_hd__decap_3
XFILLER_105_396 VGND VGND VPWR VPWR sky130_fd_sc_hd__decap_3
XFILLER_78_203 VGND VGND VPWR VPWR sky130_fd_sc_hd__decap_3
XFILLER_115_60 VGND VGND VPWR VPWR sky130_fd_sc_hd__decap_3
XFILLER_19_314 VGND VGND VPWR VPWR sky130_fd_sc_hd__decap_3
XFILLER_93_217 VGND VGND VPWR VPWR sky130_fd_sc_hd__decap_3
XFILLER_46_111 VGND VGND VPWR VPWR sky130_fd_sc_hd__fill_2
XFILLER_46_133 VGND VGND VPWR VPWR sky130_fd_sc_hd__decap_3
XFILLER_74_431 VGND VGND VPWR VPWR sky130_fd_sc_hd__decap_3
XTAP_TAPCELL_ROW_70_1093 VGND VPWR sky130_fd_sc_hd__tapvpwrvgnd_1
XFILLER_46_144 VGND VGND VPWR VPWR sky130_fd_sc_hd__decap_3
XFILLER_47_667 VGND VGND VPWR VPWR sky130_fd_sc_hd__decap_3
XFILLER_74_464 VGND VGND VPWR VPWR sky130_fd_sc_hd__fill_1
XTAP_TAPCELL_ROW_109_1557 VGND VPWR sky130_fd_sc_hd__tapvpwrvgnd_1
XFILLER_34_339 VGND VGND VPWR VPWR sky130_fd_sc_hd__decap_3
XFILLER_46_188 VGND VGND VPWR VPWR sky130_fd_sc_hd__decap_3
XFILLER_61_158 VGND VGND VPWR VPWR sky130_fd_sc_hd__decap_3
XFILLER_61_169 VGND VGND VPWR VPWR sky130_fd_sc_hd__decap_3
XFILLER_30_501 VGND VGND VPWR VPWR sky130_fd_sc_hd__decap_3
XFILLER_91_63 VGND VGND VPWR VPWR sky130_fd_sc_hd__decap_3
XTAP_TAPCELL_ROW_53_890 VGND VPWR sky130_fd_sc_hd__tapvpwrvgnd_1
XFILLER_30_589 VGND VGND VPWR VPWR sky130_fd_sc_hd__decap_3
XFILLER_115_105 VGND VGND VPWR VPWR sky130_fd_sc_hd__decap_3
XFILLER_116_606 VGND VGND VPWR VPWR sky130_fd_sc_hd__decap_3
XFILLER_116_617 VGND VGND VPWR VPWR sky130_fd_sc_hd__decap_3
XFILLER_6_251 VGND VGND VPWR VPWR sky130_fd_sc_hd__fill_1
Xhold708 _6869_/Q VGND VGND VPWR VPWR _6869_/D sky130_fd_sc_hd__dlygate4sd3_1
Xhold719 _6857_/Q VGND VGND VPWR VPWR _6857_/D sky130_fd_sc_hd__dlygate4sd3_1
XFILLER_34_3 VGND VGND VPWR VPWR sky130_fd_sc_hd__decap_3
XFILLER_69_225 VGND VGND VPWR VPWR sky130_fd_sc_hd__decap_3
XFILLER_97_523 VGND VGND VPWR VPWR sky130_fd_sc_hd__decap_3
X_5120_ _5120_/A _5120_/B VGND VGND VPWR VPWR _6984_/D sky130_fd_sc_hd__nor2_2
XFILLER_111_333 VGND VGND VPWR VPWR sky130_fd_sc_hd__decap_3
XFILLER_69_258 VGND VGND VPWR VPWR sky130_fd_sc_hd__decap_3
X_5051_ _5073_/A _5050_/X _5054_/A VGND VGND VPWR VPWR _5051_/X sky130_fd_sc_hd__a21o_2
XFILLER_111_388 VGND VGND VPWR VPWR sky130_fd_sc_hd__decap_3
XFILLER_84_228 VGND VGND VPWR VPWR sky130_fd_sc_hd__decap_3
XFILLER_111_399 VGND VGND VPWR VPWR sky130_fd_sc_hd__decap_3
XFILLER_37_100 VGND VGND VPWR VPWR sky130_fd_sc_hd__decap_3
XFILLER_37_122 VGND VGND VPWR VPWR sky130_fd_sc_hd__decap_3
XFILLER_38_634 VGND VGND VPWR VPWR sky130_fd_sc_hd__fill_2
XFILLER_65_420 VGND VGND VPWR VPWR sky130_fd_sc_hd__decap_3
XTAP_TAPCELL_ROW_88_1310 VGND VPWR sky130_fd_sc_hd__tapvpwrvgnd_1
XFILLER_37_155 VGND VGND VPWR VPWR sky130_fd_sc_hd__decap_3
XFILLER_92_261 VGND VGND VPWR VPWR sky130_fd_sc_hd__decap_3
XFILLER_25_317 VGND VGND VPWR VPWR sky130_fd_sc_hd__decap_3
XFILLER_80_412 VGND VGND VPWR VPWR sky130_fd_sc_hd__decap_3
XPHY_EDGE_ROW_9_Left_126 VGND VGND VPWR VPWR sky130_fd_sc_hd__decap_3
XFILLER_52_147 VGND VGND VPWR VPWR sky130_fd_sc_hd__decap_3
XFILLER_33_361 VGND VGND VPWR VPWR sky130_fd_sc_hd__decap_3
XFILLER_40_309 VGND VGND VPWR VPWR sky130_fd_sc_hd__decap_3
XFILLER_61_681 VGND VGND VPWR VPWR sky130_fd_sc_hd__fill_2
XFILLER_80_489 VGND VGND VPWR VPWR sky130_fd_sc_hd__decap_3
X_4904_ _4903_/A _4904_/B VGND VGND VPWR VPWR _4904_/X sky130_fd_sc_hd__and2b_2
XTAP_TAPCELL_ROW_23_529 VGND VPWR sky130_fd_sc_hd__tapvpwrvgnd_1
XFILLER_21_534 VGND VGND VPWR VPWR sky130_fd_sc_hd__fill_1
XFILLER_33_383 VGND VGND VPWR VPWR sky130_fd_sc_hd__decap_3
X_4835_ _4467_/B _3709_/X _4832_/X _4834_/Y VGND VGND VPWR VPWR _4835_/X sky130_fd_sc_hd__a31o_2
X_4766_ _4766_/A VGND VGND VPWR VPWR _4766_/Y sky130_fd_sc_hd__inv_2
X_6505_ _6535_/A VGND VGND VPWR VPWR _6505_/Y sky130_fd_sc_hd__inv_2
X_4697_ _4697_/A _6984_/Q _5670_/B VGND VGND VPWR VPWR _5120_/A sky130_fd_sc_hd__and3_2
XFILLER_105_9 VGND VGND VPWR VPWR sky130_fd_sc_hd__fill_2
XFILLER_106_116 VGND VGND VPWR VPWR sky130_fd_sc_hd__decap_3
XFILLER_106_138 VGND VGND VPWR VPWR sky130_fd_sc_hd__fill_2
XFILLER_20_26 VGND VGND VPWR VPWR sky130_fd_sc_hd__fill_2
XFILLER_20_59 VGND VGND VPWR VPWR sky130_fd_sc_hd__decap_3
X_6436_ _6570_/A VGND VGND VPWR VPWR _6436_/Y sky130_fd_sc_hd__inv_2
X_6367_ _6567_/A VGND VGND VPWR VPWR _6367_/Y sky130_fd_sc_hd__inv_2
X_3579_ _7220_/Q _4307_/A2 _3399_/A _7188_/Q VGND VGND VPWR VPWR _3579_/X sky130_fd_sc_hd__a22o_2
XFILLER_0_416 VGND VGND VPWR VPWR sky130_fd_sc_hd__fill_1
XFILLER_102_300 VGND VGND VPWR VPWR sky130_fd_sc_hd__decap_3
XFILLER_0_449 VGND VGND VPWR VPWR sky130_fd_sc_hd__fill_2
XFILLER_102_333 VGND VGND VPWR VPWR sky130_fd_sc_hd__decap_3
XFILLER_29_35 VGND VGND VPWR VPWR sky130_fd_sc_hd__decap_3
XFILLER_88_545 VGND VGND VPWR VPWR sky130_fd_sc_hd__decap_3
X_6298_ _6611_/A VGND VGND VPWR VPWR _6298_/Y sky130_fd_sc_hd__inv_2
XFILLER_29_57 VGND VGND VPWR VPWR sky130_fd_sc_hd__decap_3
XFILLER_88_589 VGND VGND VPWR VPWR sky130_fd_sc_hd__decap_3
X_5249_ _5249_/A0 _4878_/X _5262_/S VGND VGND VPWR VPWR _7205_/D sky130_fd_sc_hd__mux2_2
XFILLER_102_399 VGND VGND VPWR VPWR sky130_fd_sc_hd__decap_3
XFILLER_28_122 VGND VGND VPWR VPWR sky130_fd_sc_hd__decap_3
XFILLER_68_291 VGND VGND VPWR VPWR sky130_fd_sc_hd__decap_3
XFILLER_75_228 VGND VGND VPWR VPWR sky130_fd_sc_hd__decap_3
XFILLER_28_144 VGND VGND VPWR VPWR sky130_fd_sc_hd__decap_3
XTAP_TAPCELL_ROW_3_287 VGND VPWR sky130_fd_sc_hd__tapvpwrvgnd_1
XFILLER_16_328 VGND VGND VPWR VPWR sky130_fd_sc_hd__decap_3
XFILLER_43_103 VGND VGND VPWR VPWR sky130_fd_sc_hd__decap_3
XFILLER_43_125 VGND VGND VPWR VPWR sky130_fd_sc_hd__decap_3
XFILLER_45_23 VGND VGND VPWR VPWR sky130_fd_sc_hd__decap_3
XFILLER_56_486 VGND VGND VPWR VPWR sky130_fd_sc_hd__decap_3
XFILLER_83_261 VGND VGND VPWR VPWR sky130_fd_sc_hd__decap_3
XFILLER_12_512 VGND VGND VPWR VPWR sky130_fd_sc_hd__decap_3
XFILLER_24_361 VGND VGND VPWR VPWR sky130_fd_sc_hd__decap_3
XFILLER_43_169 VGND VGND VPWR VPWR sky130_fd_sc_hd__decap_3
XFILLER_71_478 VGND VGND VPWR VPWR sky130_fd_sc_hd__decap_3
XFILLER_101_84 VGND VGND VPWR VPWR sky130_fd_sc_hd__decap_3
XFILLER_24_394 VGND VGND VPWR VPWR sky130_fd_sc_hd__decap_3
XFILLER_51_191 VGND VGND VPWR VPWR sky130_fd_sc_hd__decap_3
XFILLER_61_33 VGND VGND VPWR VPWR sky130_fd_sc_hd__decap_3
XTAP_TAPCELL_ROW_104_1498 VGND VPWR sky130_fd_sc_hd__tapvpwrvgnd_1
XFILLER_61_66 VGND VGND VPWR VPWR sky130_fd_sc_hd__decap_3
XFILLER_61_99 VGND VGND VPWR VPWR sky130_fd_sc_hd__decap_3
XFILLER_3_210 VGND VGND VPWR VPWR sky130_fd_sc_hd__decap_3
XFILLER_98_309 VGND VGND VPWR VPWR sky130_fd_sc_hd__decap_3
XFILLER_105_160 VGND VGND VPWR VPWR sky130_fd_sc_hd__decap_3
XFILLER_3_276 VGND VGND VPWR VPWR sky130_fd_sc_hd__decap_3
XFILLER_3_287 VGND VGND VPWR VPWR sky130_fd_sc_hd__decap_3
XTAP_TAPCELL_ROW_72_1111 VGND VPWR sky130_fd_sc_hd__tapvpwrvgnd_1
XFILLER_79_556 VGND VGND VPWR VPWR sky130_fd_sc_hd__decap_3
XFILLER_66_206 VGND VGND VPWR VPWR sky130_fd_sc_hd__decap_3
XFILLER_86_41 VGND VGND VPWR VPWR sky130_fd_sc_hd__decap_3
XFILLER_86_74 VGND VGND VPWR VPWR sky130_fd_sc_hd__decap_3
XFILLER_94_515 VGND VGND VPWR VPWR sky130_fd_sc_hd__decap_3
XFILLER_19_100 VGND VGND VPWR VPWR sky130_fd_sc_hd__decap_3
XFILLER_47_420 VGND VGND VPWR VPWR sky130_fd_sc_hd__decap_3
XFILLER_66_239 VGND VGND VPWR VPWR sky130_fd_sc_hd__decap_3
XFILLER_86_85 VGND VGND VPWR VPWR sky130_fd_sc_hd__decap_3
XFILLER_94_548 VGND VGND VPWR VPWR sky130_fd_sc_hd__decap_3
XFILLER_19_155 VGND VGND VPWR VPWR sky130_fd_sc_hd__decap_3
XFILLER_47_464 VGND VGND VPWR VPWR sky130_fd_sc_hd__fill_1
XFILLER_34_114 VGND VGND VPWR VPWR sky130_fd_sc_hd__decap_3
XFILLER_34_158 VGND VGND VPWR VPWR sky130_fd_sc_hd__decap_3
XFILLER_62_445 VGND VGND VPWR VPWR sky130_fd_sc_hd__decap_3
XFILLER_15_361 VGND VGND VPWR VPWR sky130_fd_sc_hd__decap_3
XFILLER_22_309 VGND VGND VPWR VPWR sky130_fd_sc_hd__decap_3
XFILLER_62_489 VGND VGND VPWR VPWR sky130_fd_sc_hd__decap_3
XTAP_TAPCELL_ROW_83_1251 VGND VPWR sky130_fd_sc_hd__tapvpwrvgnd_1
XFILLER_30_353 VGND VGND VPWR VPWR sky130_fd_sc_hd__decap_3
X_4620_ _4620_/A _5003_/A _4620_/C _5032_/A VGND VGND VPWR VPWR _4624_/B sky130_fd_sc_hd__and4_4
XFILLER_30_386 VGND VGND VPWR VPWR sky130_fd_sc_hd__decap_3
XFILLER_116_414 VGND VGND VPWR VPWR sky130_fd_sc_hd__decap_3
XFILLER_116_436 VGND VGND VPWR VPWR sky130_fd_sc_hd__fill_2
X_7270_ _7365_/CLK _7270_/D _6550_/Y VGND VGND VPWR VPWR _7270_/Q sky130_fd_sc_hd__dfrtp_2
X_4482_ _4482_/A0 _7306_/Q _4491_/S VGND VGND VPWR VPWR _7338_/D sky130_fd_sc_hd__mux2_2
X_3502_ _3502_/A _3502_/B _3485_/C VGND VGND VPWR VPWR _3502_/X sky130_fd_sc_hd__or3b_2
XFILLER_104_609 VGND VGND VPWR VPWR sky130_fd_sc_hd__decap_3
XFILLER_116_458 VGND VGND VPWR VPWR sky130_fd_sc_hd__decap_3
XFILLER_103_119 VGND VGND VPWR VPWR sky130_fd_sc_hd__decap_3
XTAP_TAPCELL_ROW_94_1380 VGND VPWR sky130_fd_sc_hd__tapvpwrvgnd_1
X_5103_ _5103_/A1 _5047_/Y _5099_/X _5102_/X VGND VGND VPWR VPWR _5651_/A sky130_fd_sc_hd__a31oi_2
X_3364_ _3362_/X _5294_/B _3371_/A VGND VGND VPWR VPWR _3399_/B sky130_fd_sc_hd__a21boi_2
XFILLER_111_141 VGND VGND VPWR VPWR sky130_fd_sc_hd__decap_3
Xhold1205 _7134_/Q VGND VGND VPWR VPWR _5398_/A0 sky130_fd_sc_hd__dlygate4sd3_1
XFILLER_38_431 VGND VGND VPWR VPWR sky130_fd_sc_hd__decap_3
XFILLER_57_228 VGND VGND VPWR VPWR sky130_fd_sc_hd__decap_3
X_5034_ _5103_/A1 _5031_/X _5032_/Y _3618_/X _5033_/X VGND VGND VPWR VPWR _5658_/B
+ sky130_fd_sc_hd__a221o_2
XFILLER_38_464 VGND VGND VPWR VPWR sky130_fd_sc_hd__fill_1
XFILLER_72_209 VGND VGND VPWR VPWR sky130_fd_sc_hd__decap_3
XTAP_TAPCELL_ROW_56_919 VGND VPWR sky130_fd_sc_hd__tapvpwrvgnd_1
XFILLER_65_272 VGND VGND VPWR VPWR sky130_fd_sc_hd__decap_3
XTAP_TAPCELL_ROW_0_235 VGND VPWR sky130_fd_sc_hd__tapvpwrvgnd_1
XFILLER_25_125 VGND VGND VPWR VPWR sky130_fd_sc_hd__decap_3
XFILLER_80_231 VGND VGND VPWR VPWR sky130_fd_sc_hd__decap_3
X_6985_ _7396_/CLK _6985_/D _6265_/Y VGND VGND VPWR VPWR _6985_/Q sky130_fd_sc_hd__dfrtp_2
XTAP_TAPCELL_ROW_0_257 VGND VPWR sky130_fd_sc_hd__tapvpwrvgnd_1
XTAP_TAPCELL_ROW_0_246 VGND VPWR sky130_fd_sc_hd__tapvpwrvgnd_1
XFILLER_13_309 VGND VGND VPWR VPWR sky130_fd_sc_hd__decap_3
XFILLER_15_15 VGND VGND VPWR VPWR sky130_fd_sc_hd__decap_3
XFILLER_15_48 VGND VGND VPWR VPWR sky130_fd_sc_hd__decap_3
XFILLER_25_169 VGND VGND VPWR VPWR sky130_fd_sc_hd__decap_3
XFILLER_40_106 VGND VGND VPWR VPWR sky130_fd_sc_hd__decap_3
XFILLER_53_478 VGND VGND VPWR VPWR sky130_fd_sc_hd__decap_3
XFILLER_80_253 VGND VGND VPWR VPWR sky130_fd_sc_hd__decap_3
XTAP_TAPCELL_ROW_36_687 VGND VPWR sky130_fd_sc_hd__tapvpwrvgnd_1
XFILLER_34_681 VGND VGND VPWR VPWR sky130_fd_sc_hd__decap_3
XFILLER_40_139 VGND VGND VPWR VPWR sky130_fd_sc_hd__fill_1
XFILLER_80_286 VGND VGND VPWR VPWR sky130_fd_sc_hd__decap_3
XFILLER_31_25 VGND VGND VPWR VPWR sky130_fd_sc_hd__decap_3
X_4818_ _7002_/Q _4834_/A VGND VGND VPWR VPWR _4818_/Y sky130_fd_sc_hd__nand2_2
X_4749_ _7006_/Q _4749_/B VGND VGND VPWR VPWR _4750_/C sky130_fd_sc_hd__nor2_2
XFILLER_103_6 VGND VGND VPWR VPWR sky130_fd_sc_hd__decap_3
XFILLER_107_458 VGND VGND VPWR VPWR sky130_fd_sc_hd__decap_3
X_6419_ _6578_/A VGND VGND VPWR VPWR _6419_/Y sky130_fd_sc_hd__inv_2
X_7399_ _7406_/CLK _7399_/D _6679_/Y VGND VGND VPWR VPWR _7399_/Q sky130_fd_sc_hd__dfrtp_2
XFILLER_103_620 VGND VGND VPWR VPWR sky130_fd_sc_hd__decap_3
XTAP_TAPCELL_ROW_8_346 VGND VPWR sky130_fd_sc_hd__tapvpwrvgnd_1
XFILLER_102_141 VGND VGND VPWR VPWR sky130_fd_sc_hd__decap_3
XFILLER_76_504 VGND VGND VPWR VPWR sky130_fd_sc_hd__decap_3
XFILLER_88_353 VGND VGND VPWR VPWR sky130_fd_sc_hd__decap_3
XFILLER_88_386 VGND VGND VPWR VPWR sky130_fd_sc_hd__fill_2
XFILLER_29_431 VGND VGND VPWR VPWR sky130_fd_sc_hd__decap_3
XFILLER_56_44 VGND VGND VPWR VPWR sky130_fd_sc_hd__decap_3
XFILLER_44_412 VGND VGND VPWR VPWR sky130_fd_sc_hd__decap_3
XFILLER_56_283 VGND VGND VPWR VPWR sky130_fd_sc_hd__decap_3
XFILLER_56_77 VGND VGND VPWR VPWR sky130_fd_sc_hd__decap_3
XFILLER_56_88 VGND VGND VPWR VPWR sky130_fd_sc_hd__decap_3
XFILLER_84_570 VGND VGND VPWR VPWR sky130_fd_sc_hd__decap_3
XTAP_TAPCELL_ROW_106_1527 VGND VPWR sky130_fd_sc_hd__tapvpwrvgnd_1
XFILLER_16_125 VGND VGND VPWR VPWR sky130_fd_sc_hd__decap_3
XFILLER_16_147 VGND VGND VPWR VPWR sky130_fd_sc_hd__decap_3
XFILLER_44_456 VGND VGND VPWR VPWR sky130_fd_sc_hd__decap_3
XFILLER_71_231 VGND VGND VPWR VPWR sky130_fd_sc_hd__decap_3
XFILLER_112_94 VGND VGND VPWR VPWR sky130_fd_sc_hd__decap_3
XFILLER_44_489 VGND VGND VPWR VPWR sky130_fd_sc_hd__decap_3
XFILLER_71_264 VGND VGND VPWR VPWR sky130_fd_sc_hd__decap_3
XFILLER_72_21 VGND VGND VPWR VPWR sky130_fd_sc_hd__decap_3
XFILLER_72_32 VGND VGND VPWR VPWR sky130_fd_sc_hd__fill_1
XFILLER_31_128 VGND VGND VPWR VPWR sky130_fd_sc_hd__decap_3
XFILLER_12_342 VGND VGND VPWR VPWR sky130_fd_sc_hd__fill_1
XFILLER_12_386 VGND VGND VPWR VPWR sky130_fd_sc_hd__decap_3
XFILLER_8_368 VGND VGND VPWR VPWR sky130_fd_sc_hd__decap_3
XFILLER_21_80 VGND VGND VPWR VPWR sky130_fd_sc_hd__decap_3
XFILLER_4_530 VGND VGND VPWR VPWR sky130_fd_sc_hd__fill_2
XFILLER_4_541 VGND VGND VPWR VPWR sky130_fd_sc_hd__decap_3
XFILLER_113_417 VGND VGND VPWR VPWR sky130_fd_sc_hd__decap_3
XFILLER_106_480 VGND VGND VPWR VPWR sky130_fd_sc_hd__decap_3
XFILLER_79_375 VGND VGND VPWR VPWR sky130_fd_sc_hd__decap_3
XFILLER_97_95 VGND VGND VPWR VPWR sky130_fd_sc_hd__decap_3
XFILLER_67_526 VGND VGND VPWR VPWR sky130_fd_sc_hd__decap_3
XFILLER_67_559 VGND VGND VPWR VPWR sky130_fd_sc_hd__fill_1
XFILLER_94_312 VGND VGND VPWR VPWR sky130_fd_sc_hd__decap_3
XFILLER_54_209 VGND VGND VPWR VPWR sky130_fd_sc_hd__decap_3
XFILLER_94_345 VGND VGND VPWR VPWR sky130_fd_sc_hd__decap_3
XFILLER_47_261 VGND VGND VPWR VPWR sky130_fd_sc_hd__decap_3
XFILLER_75_570 VGND VGND VPWR VPWR sky130_fd_sc_hd__decap_3
XFILLER_35_434 VGND VGND VPWR VPWR sky130_fd_sc_hd__decap_3
XFILLER_62_231 VGND VGND VPWR VPWR sky130_fd_sc_hd__decap_3
XFILLER_22_106 VGND VGND VPWR VPWR sky130_fd_sc_hd__decap_3
X_6770_ _6965_/CLK _6770_/D VGND VGND VPWR VPWR _6770_/Q sky130_fd_sc_hd__dfxtp_2
X_5721_ _7366_/Q hold945/X _5737_/S VGND VGND VPWR VPWR _6710_/D sky130_fd_sc_hd__mux2_2
XTAP_TAPCELL_ROW_33_646 VGND VPWR sky130_fd_sc_hd__tapvpwrvgnd_1
XTAP_TAPCELL_ROW_61_988 VGND VPWR sky130_fd_sc_hd__tapvpwrvgnd_1
XPHY_EDGE_ROW_99_Left_216 VGND VGND VPWR VPWR sky130_fd_sc_hd__decap_3
XFILLER_30_150 VGND VGND VPWR VPWR sky130_fd_sc_hd__decap_3
X_5652_ _5664_/A VGND VGND VPWR VPWR _5652_/Y sky130_fd_sc_hd__inv_2
XFILLER_30_183 VGND VGND VPWR VPWR sky130_fd_sc_hd__decap_3
X_5583_ _5583_/A0 _5094_/X _5595_/B VGND VGND VPWR VPWR _7037_/D sky130_fd_sc_hd__mux2_2
X_4603_ _4603_/A1 _4595_/B _3487_/X VGND VGND VPWR VPWR _7279_/D sky130_fd_sc_hd__a21o_2
XFILLER_116_200 VGND VGND VPWR VPWR sky130_fd_sc_hd__decap_3
XFILLER_7_60 VGND VGND VPWR VPWR sky130_fd_sc_hd__decap_3
X_7322_ clkload3/A _7322_/D _6602_/Y VGND VGND VPWR VPWR _7322_/Q sky130_fd_sc_hd__dfrtp_2
X_4534_ _4534_/A0 _7280_/Q _4534_/S VGND VGND VPWR VPWR _7312_/D sky130_fd_sc_hd__mux2_2
XFILLER_7_93 VGND VGND VPWR VPWR sky130_fd_sc_hd__decap_3
XFILLER_104_406 VGND VGND VPWR VPWR sky130_fd_sc_hd__decap_3
XFILLER_104_417 VGND VGND VPWR VPWR sky130_fd_sc_hd__decap_3
X_7253_ _7258_/CLK _7253_/D _6533_/Y VGND VGND VPWR VPWR _7253_/Q sky130_fd_sc_hd__dfrtp_2
X_4465_ _5655_/B _5655_/C VGND VGND VPWR VPWR _5650_/A sky130_fd_sc_hd__nor2_2
XFILLER_104_439 VGND VGND VPWR VPWR sky130_fd_sc_hd__decap_3
XFILLER_89_139 VGND VGND VPWR VPWR sky130_fd_sc_hd__decap_3
X_7184_ _7381_/CLK _7184_/D _6464_/Y VGND VGND VPWR VPWR _7184_/Q sky130_fd_sc_hd__dfrtp_2
X_4396_ _4396_/A _4444_/B VGND VGND VPWR VPWR _4648_/A sky130_fd_sc_hd__nor2_2
X_3347_ _5640_/B _3509_/B VGND VGND VPWR VPWR _3420_/A sky130_fd_sc_hd__or2_2
XTAP_TAPCELL_ROW_5_316 VGND VPWR sky130_fd_sc_hd__tapvpwrvgnd_1
XFILLER_98_662 VGND VGND VPWR VPWR sky130_fd_sc_hd__fill_1
XFILLER_100_634 VGND VGND VPWR VPWR sky130_fd_sc_hd__decap_3
XFILLER_100_645 VGND VGND VPWR VPWR sky130_fd_sc_hd__fill_2
XFILLER_112_483 VGND VGND VPWR VPWR sky130_fd_sc_hd__decap_3
XFILLER_85_334 VGND VGND VPWR VPWR sky130_fd_sc_hd__fill_2
XFILLER_97_172 VGND VGND VPWR VPWR sky130_fd_sc_hd__decap_3
Xhold1002 _7265_/Q VGND VGND VPWR VPWR _4946_/A0 sky130_fd_sc_hd__dlygate4sd3_1
Xhold1013 _7201_/Q VGND VGND VPWR VPWR _5258_/A0 sky130_fd_sc_hd__dlygate4sd3_1
Xhold1024 _7277_/Q VGND VGND VPWR VPWR _4735_/A0 sky130_fd_sc_hd__dlygate4sd3_1
XFILLER_85_367 VGND VGND VPWR VPWR sky130_fd_sc_hd__decap_3
Xhold1035 _7193_/Q VGND VGND VPWR VPWR _5274_/A0 sky130_fd_sc_hd__dlygate4sd3_1
Xhold1046 _7208_/Q VGND VGND VPWR VPWR _5243_/A0 sky130_fd_sc_hd__dlygate4sd3_1
Xhold1057 _7385_/Q VGND VGND VPWR VPWR _3864_/A0 sky130_fd_sc_hd__dlygate4sd3_1
X_5017_ _5018_/A _5017_/B VGND VGND VPWR VPWR _5017_/Y sky130_fd_sc_hd__xnor2_2
XFILLER_26_401 VGND VGND VPWR VPWR sky130_fd_sc_hd__decap_3
XFILLER_73_529 VGND VGND VPWR VPWR sky130_fd_sc_hd__decap_3
XFILLER_85_389 VGND VGND VPWR VPWR sky130_fd_sc_hd__decap_3
Xhold1068 _7342_/Q VGND VGND VPWR VPWR _4474_/A0 sky130_fd_sc_hd__dlygate4sd3_1
Xhold1079 _7309_/Q VGND VGND VPWR VPWR _4542_/A sky130_fd_sc_hd__dlygate4sd3_1
XFILLER_38_283 VGND VGND VPWR VPWR sky130_fd_sc_hd__fill_1
XFILLER_53_231 VGND VGND VPWR VPWR sky130_fd_sc_hd__decap_3
XFILLER_26_58 VGND VGND VPWR VPWR sky130_fd_sc_hd__decap_3
XFILLER_53_253 VGND VGND VPWR VPWR sky130_fd_sc_hd__fill_1
XFILLER_53_275 VGND VGND VPWR VPWR sky130_fd_sc_hd__decap_3
X_6968_ _6968_/CLK _6968_/D VGND VGND VPWR VPWR _6968_/Q sky130_fd_sc_hd__dfxtp_2
X_6899_ _6929_/CLK _6899_/D VGND VGND VPWR VPWR _6899_/Q sky130_fd_sc_hd__dfxtp_2
XFILLER_21_172 VGND VGND VPWR VPWR sky130_fd_sc_hd__decap_3
XTAP_TAPCELL_ROW_101_1468 VGND VPWR sky130_fd_sc_hd__tapvpwrvgnd_1
XFILLER_107_211 VGND VGND VPWR VPWR sky130_fd_sc_hd__decap_3
XFILLER_5_305 VGND VGND VPWR VPWR sky130_fd_sc_hd__decap_3
XFILLER_5_349 VGND VGND VPWR VPWR sky130_fd_sc_hd__decap_3
XFILLER_107_266 VGND VGND VPWR VPWR sky130_fd_sc_hd__decap_3
XFILLER_107_288 VGND VGND VPWR VPWR sky130_fd_sc_hd__decap_3
XFILLER_3_18 VGND VGND VPWR VPWR sky130_fd_sc_hd__decap_3
Xhold880 _7096_/Q VGND VGND VPWR VPWR _7096_/D sky130_fd_sc_hd__dlygate4sd3_1
Xhold891 _7081_/Q VGND VGND VPWR VPWR _7081_/D sky130_fd_sc_hd__dlygate4sd3_1
XFILLER_107_72 VGND VGND VPWR VPWR sky130_fd_sc_hd__decap_3
XFILLER_1_555 VGND VGND VPWR VPWR sky130_fd_sc_hd__decap_3
XFILLER_49_515 VGND VGND VPWR VPWR sky130_fd_sc_hd__fill_1
XFILLER_67_32 VGND VGND VPWR VPWR sky130_fd_sc_hd__decap_3
XFILLER_88_150 VGND VGND VPWR VPWR sky130_fd_sc_hd__decap_3
XFILLER_89_662 VGND VGND VPWR VPWR sky130_fd_sc_hd__decap_3
XFILLER_89_673 VGND VGND VPWR VPWR sky130_fd_sc_hd__decap_3
XFILLER_103_483 VGND VGND VPWR VPWR sky130_fd_sc_hd__decap_3
XTAP_TAPCELL_ROW_112_1597 VGND VPWR sky130_fd_sc_hd__tapvpwrvgnd_1
XFILLER_67_76 VGND VGND VPWR VPWR sky130_fd_sc_hd__decap_3
XFILLER_29_272 VGND VGND VPWR VPWR sky130_fd_sc_hd__decap_3
XFILLER_57_570 VGND VGND VPWR VPWR sky130_fd_sc_hd__fill_1
XFILLER_76_389 VGND VGND VPWR VPWR sky130_fd_sc_hd__fill_2
XFILLER_91_315 VGND VGND VPWR VPWR sky130_fd_sc_hd__fill_2
XFILLER_91_326 VGND VGND VPWR VPWR sky130_fd_sc_hd__decap_3
XFILLER_17_434 VGND VGND VPWR VPWR sky130_fd_sc_hd__decap_3
XFILLER_91_337 VGND VGND VPWR VPWR sky130_fd_sc_hd__decap_3
XFILLER_32_404 VGND VGND VPWR VPWR sky130_fd_sc_hd__decap_3
XFILLER_44_253 VGND VGND VPWR VPWR sky130_fd_sc_hd__decap_3
XFILLER_83_86 VGND VGND VPWR VPWR sky130_fd_sc_hd__decap_3
XTAP_TAPCELL_ROW_67_1054 VGND VPWR sky130_fd_sc_hd__tapvpwrvgnd_1
XFILLER_44_286 VGND VGND VPWR VPWR sky130_fd_sc_hd__decap_3
XTAP_TAPCELL_ROW_80_1210 VGND VPWR sky130_fd_sc_hd__tapvpwrvgnd_1
XFILLER_12_172 VGND VGND VPWR VPWR sky130_fd_sc_hd__decap_3
XTAP_TAPCELL_ROW_30_616 VGND VPWR sky130_fd_sc_hd__tapvpwrvgnd_1
XFILLER_12_183 VGND VGND VPWR VPWR sky130_fd_sc_hd__decap_3
XFILLER_40_492 VGND VGND VPWR VPWR sky130_fd_sc_hd__decap_3
XFILLER_66_6 VGND VGND VPWR VPWR sky130_fd_sc_hd__decap_3
XFILLER_8_165 VGND VGND VPWR VPWR sky130_fd_sc_hd__decap_3
XTAP_TAPCELL_ROW_10_373 VGND VPWR sky130_fd_sc_hd__tapvpwrvgnd_1
XFILLER_4_360 VGND VGND VPWR VPWR sky130_fd_sc_hd__decap_3
XTAP_TAPCELL_ROW_78_1183 VGND VPWR sky130_fd_sc_hd__tapvpwrvgnd_1
XFILLER_99_426 VGND VGND VPWR VPWR sky130_fd_sc_hd__decap_3
XFILLER_113_225 VGND VGND VPWR VPWR sky130_fd_sc_hd__fill_1
XFILLER_4_371 VGND VGND VPWR VPWR sky130_fd_sc_hd__decap_3
X_4250_ _7101_/Q _4351_/A2 _4267_/B1 _7165_/Q VGND VGND VPWR VPWR _4250_/X sky130_fd_sc_hd__a22o_2
X_4181_ _7200_/Q _3968_/S _4354_/B1 _7392_/Q VGND VGND VPWR VPWR _4181_/X sky130_fd_sc_hd__a22o_2
XFILLER_67_334 VGND VGND VPWR VPWR sky130_fd_sc_hd__fill_2
XFILLER_95_676 VGND VGND VPWR VPWR sky130_fd_sc_hd__decap_3
XFILLER_67_389 VGND VGND VPWR VPWR sky130_fd_sc_hd__decap_3
XFILLER_94_186 VGND VGND VPWR VPWR sky130_fd_sc_hd__decap_3
XTAP_TAPCELL_ROW_38_705 VGND VPWR sky130_fd_sc_hd__tapvpwrvgnd_1
XFILLER_63_540 VGND VGND VPWR VPWR sky130_fd_sc_hd__decap_3
XFILLER_82_337 VGND VGND VPWR VPWR sky130_fd_sc_hd__decap_3
XFILLER_94_197 VGND VGND VPWR VPWR sky130_fd_sc_hd__decap_3
XFILLER_35_242 VGND VGND VPWR VPWR sky130_fd_sc_hd__decap_3
X_6822_ _6972_/CLK _6822_/D VGND VGND VPWR VPWR _6822_/Q sky130_fd_sc_hd__dfxtp_2
XFILLER_50_223 VGND VGND VPWR VPWR sky130_fd_sc_hd__decap_3
XTAP_TAPCELL_ROW_18_473 VGND VPWR sky130_fd_sc_hd__tapvpwrvgnd_1
XTAP_TAPCELL_ROW_18_462 VGND VPWR sky130_fd_sc_hd__tapvpwrvgnd_1
X_6753_ _6978_/CLK _6753_/D VGND VGND VPWR VPWR _6753_/Q sky130_fd_sc_hd__dfxtp_2
X_6684_ _6684_/A VGND VGND VPWR VPWR _6684_/Y sky130_fd_sc_hd__inv_2
X_3896_ _3880_/X _3885_/X _3895_/X _5151_/A VGND VGND VPWR VPWR _3896_/Y sky130_fd_sc_hd__o31ai_2
XFILLER_12_27 VGND VGND VPWR VPWR sky130_fd_sc_hd__fill_1
XFILLER_12_38 VGND VGND VPWR VPWR sky130_fd_sc_hd__decap_3
X_5566_ _5566_/A1 _4975_/A _4860_/Y VGND VGND VPWR VPWR _7051_/D sky130_fd_sc_hd__o21a_2
X_7305_ _7338_/CLK _7305_/D _6585_/Y VGND VGND VPWR VPWR _7305_/Q sky130_fd_sc_hd__dfrtp_2
X_4517_ _4517_/A0 _7289_/Q _4534_/S VGND VGND VPWR VPWR _7321_/D sky130_fd_sc_hd__mux2_2
XFILLER_104_225 VGND VGND VPWR VPWR sky130_fd_sc_hd__decap_3
X_7236_ _7361_/CLK _7236_/D _6516_/Y VGND VGND VPWR VPWR _7236_/Q sky130_fd_sc_hd__dfrtp_2
X_4448_ _4444_/X _4447_/Y _4413_/A VGND VGND VPWR VPWR _4448_/X sky130_fd_sc_hd__o21a_2
XFILLER_86_621 VGND VGND VPWR VPWR sky130_fd_sc_hd__decap_3
X_7167_ _7294_/CLK _7167_/D _6447_/Y VGND VGND VPWR VPWR _7167_/Q sky130_fd_sc_hd__dfrtp_2
X_4379_ _4938_/B _4379_/B VGND VGND VPWR VPWR _4937_/A sky130_fd_sc_hd__or2_2
XFILLER_98_492 VGND VGND VPWR VPWR sky130_fd_sc_hd__decap_3
XFILLER_100_442 VGND VGND VPWR VPWR sky130_fd_sc_hd__decap_3
XFILLER_112_280 VGND VGND VPWR VPWR sky130_fd_sc_hd__decap_3
XFILLER_37_24 VGND VGND VPWR VPWR sky130_fd_sc_hd__decap_3
XFILLER_85_142 VGND VGND VPWR VPWR sky130_fd_sc_hd__decap_3
XFILLER_86_654 VGND VGND VPWR VPWR sky130_fd_sc_hd__decap_3
X_7098_ clkload6/A _7098_/D _6378_/Y VGND VGND VPWR VPWR _7098_/Q sky130_fd_sc_hd__dfrtp_2
XFILLER_100_486 VGND VGND VPWR VPWR sky130_fd_sc_hd__decap_3
XFILLER_18_209 VGND VGND VPWR VPWR sky130_fd_sc_hd__fill_1
XFILLER_37_46 VGND VGND VPWR VPWR sky130_fd_sc_hd__decap_3
XFILLER_37_57 VGND VGND VPWR VPWR sky130_fd_sc_hd__decap_3
XFILLER_73_304 VGND VGND VPWR VPWR sky130_fd_sc_hd__decap_3
XFILLER_86_687 VGND VGND VPWR VPWR sky130_fd_sc_hd__decap_3
XFILLER_39_592 VGND VGND VPWR VPWR sky130_fd_sc_hd__fill_1
XFILLER_85_197 VGND VGND VPWR VPWR sky130_fd_sc_hd__decap_3
XFILLER_26_275 VGND VGND VPWR VPWR sky130_fd_sc_hd__decap_3
XFILLER_41_212 VGND VGND VPWR VPWR sky130_fd_sc_hd__decap_3
XFILLER_53_12 VGND VGND VPWR VPWR sky130_fd_sc_hd__decap_3
XFILLER_53_45 VGND VGND VPWR VPWR sky130_fd_sc_hd__decap_3
XFILLER_81_370 VGND VGND VPWR VPWR sky130_fd_sc_hd__decap_3
XFILLER_41_256 VGND VGND VPWR VPWR sky130_fd_sc_hd__decap_3
XFILLER_53_78 VGND VGND VPWR VPWR sky130_fd_sc_hd__decap_3
XFILLER_108_520 VGND VGND VPWR VPWR sky130_fd_sc_hd__decap_3
XFILLER_5_113 VGND VGND VPWR VPWR sky130_fd_sc_hd__decap_3
XFILLER_108_542 VGND VGND VPWR VPWR sky130_fd_sc_hd__decap_3
XFILLER_5_146 VGND VGND VPWR VPWR sky130_fd_sc_hd__decap_3
XFILLER_108_575 VGND VGND VPWR VPWR sky130_fd_sc_hd__fill_1
XTAP_TAPCELL_ROW_114_1615 VGND VPWR sky130_fd_sc_hd__tapvpwrvgnd_1
XFILLER_78_20 VGND VGND VPWR VPWR sky130_fd_sc_hd__decap_3
XFILLER_78_75 VGND VGND VPWR VPWR sky130_fd_sc_hd__fill_2
XFILLER_96_418 VGND VGND VPWR VPWR sky130_fd_sc_hd__fill_2
XFILLER_49_312 VGND VGND VPWR VPWR sky130_fd_sc_hd__decap_3
XFILLER_77_610 VGND VGND VPWR VPWR sky130_fd_sc_hd__decap_3
XFILLER_78_97 VGND VGND VPWR VPWR sky130_fd_sc_hd__decap_3
XFILLER_89_470 VGND VGND VPWR VPWR sky130_fd_sc_hd__decap_3
XFILLER_49_367 VGND VGND VPWR VPWR sky130_fd_sc_hd__decap_3
XFILLER_92_613 VGND VGND VPWR VPWR sky130_fd_sc_hd__decap_3
XFILLER_94_41 VGND VGND VPWR VPWR sky130_fd_sc_hd__decap_3
XFILLER_17_220 VGND VGND VPWR VPWR sky130_fd_sc_hd__decap_3
XFILLER_91_134 VGND VGND VPWR VPWR sky130_fd_sc_hd__fill_1
XFILLER_94_85 VGND VGND VPWR VPWR sky130_fd_sc_hd__decap_3
XFILLER_17_231 VGND VGND VPWR VPWR sky130_fd_sc_hd__decap_3
XFILLER_17_242 VGND VGND VPWR VPWR sky130_fd_sc_hd__decap_3
XFILLER_27_90 VGND VGND VPWR VPWR sky130_fd_sc_hd__decap_3
XFILLER_45_540 VGND VGND VPWR VPWR sky130_fd_sc_hd__fill_1
XFILLER_91_156 VGND VGND VPWR VPWR sky130_fd_sc_hd__decap_3
XFILLER_17_297 VGND VGND VPWR VPWR sky130_fd_sc_hd__decap_3
XFILLER_60_510 VGND VGND VPWR VPWR sky130_fd_sc_hd__decap_3
XFILLER_72_392 VGND VGND VPWR VPWR sky130_fd_sc_hd__decap_3
XFILLER_91_189 VGND VGND VPWR VPWR sky130_fd_sc_hd__decap_3
XTAP_TAPCELL_ROW_15_432 VGND VPWR sky130_fd_sc_hd__tapvpwrvgnd_1
XFILLER_20_418 VGND VGND VPWR VPWR sky130_fd_sc_hd__fill_2
XFILLER_32_267 VGND VGND VPWR VPWR sky130_fd_sc_hd__decap_3
XFILLER_32_289 VGND VGND VPWR VPWR sky130_fd_sc_hd__decap_3
XFILLER_60_587 VGND VGND VPWR VPWR sky130_fd_sc_hd__fill_1
XFILLER_60_598 VGND VGND VPWR VPWR sky130_fd_sc_hd__fill_2
X_3750_ _3750_/A1 _4791_/A1 wire556/X VGND VGND VPWR VPWR _7398_/D sky130_fd_sc_hd__a21bo_2
XTAP_TAPCELL_ROW_43_763 VGND VPWR sky130_fd_sc_hd__tapvpwrvgnd_1
XFILLER_9_452 VGND VGND VPWR VPWR sky130_fd_sc_hd__decap_3
X_3681_ _3674_/Y _3825_/B1 _3826_/A2 _3676_/Y _3680_/X VGND VGND VPWR VPWR _3682_/B
+ sky130_fd_sc_hd__a221o_2
XFILLER_64_3 VGND VGND VPWR VPWR sky130_fd_sc_hd__decap_3
X_5282_ _5282_/A1 _5238_/X _3610_/Y VGND VGND VPWR VPWR _7189_/D sky130_fd_sc_hd__a21o_2
X_4302_ _7224_/Q _3377_/X _3556_/A _4301_/X VGND VGND VPWR VPWR _4302_/X sky130_fd_sc_hd__a211o_2
XFILLER_99_234 VGND VGND VPWR VPWR sky130_fd_sc_hd__decap_3
XFILLER_99_223 VGND VGND VPWR VPWR sky130_fd_sc_hd__fill_1
XFILLER_114_556 VGND VGND VPWR VPWR sky130_fd_sc_hd__decap_3
XFILLER_114_567 VGND VGND VPWR VPWR sky130_fd_sc_hd__decap_3
XFILLER_59_109 VGND VGND VPWR VPWR sky130_fd_sc_hd__decap_3
X_7021_ _7359_/CLK _7021_/D _6301_/Y VGND VGND VPWR VPWR _7021_/Q sky130_fd_sc_hd__dfrtp_2
X_4233_ _7323_/Q _3977_/S _4530_/S _7291_/Q VGND VGND VPWR VPWR _4233_/X sky130_fd_sc_hd__a22o_2
XFILLER_99_267 VGND VGND VPWR VPWR sky130_fd_sc_hd__decap_3
XFILLER_68_610 VGND VGND VPWR VPWR sky130_fd_sc_hd__fill_2
XFILLER_68_621 VGND VGND VPWR VPWR sky130_fd_sc_hd__decap_3
XFILLER_68_632 VGND VGND VPWR VPWR sky130_fd_sc_hd__decap_3
XFILLER_114_29 VGND VGND VPWR VPWR sky130_fd_sc_hd__decap_3
XFILLER_68_654 VGND VGND VPWR VPWR sky130_fd_sc_hd__decap_3
X_4164_ _7105_/Q _4218_/A2 _4267_/B1 _7169_/Q VGND VGND VPWR VPWR _4164_/X sky130_fd_sc_hd__a22o_2
XFILLER_28_507 VGND VGND VPWR VPWR sky130_fd_sc_hd__decap_3
XFILLER_28_529 VGND VGND VPWR VPWR sky130_fd_sc_hd__decap_3
XFILLER_67_153 VGND VGND VPWR VPWR sky130_fd_sc_hd__decap_3
XFILLER_95_473 VGND VGND VPWR VPWR sky130_fd_sc_hd__decap_3
X_4095_ _4095_/A _4210_/B VGND VGND VPWR VPWR _4096_/B sky130_fd_sc_hd__nand2_2
XFILLER_67_186 VGND VGND VPWR VPWR sky130_fd_sc_hd__decap_3
XFILLER_82_134 VGND VGND VPWR VPWR sky130_fd_sc_hd__decap_3
XFILLER_83_646 VGND VGND VPWR VPWR sky130_fd_sc_hd__decap_3
XFILLER_82_156 VGND VGND VPWR VPWR sky130_fd_sc_hd__decap_3
XFILLER_83_679 VGND VGND VPWR VPWR sky130_fd_sc_hd__decap_3
XFILLER_23_212 VGND VGND VPWR VPWR sky130_fd_sc_hd__fill_2
XFILLER_63_370 VGND VGND VPWR VPWR sky130_fd_sc_hd__decap_3
XFILLER_70_329 VGND VGND VPWR VPWR sky130_fd_sc_hd__decap_3
XFILLER_82_189 VGND VGND VPWR VPWR sky130_fd_sc_hd__decap_3
XFILLER_51_554 VGND VGND VPWR VPWR sky130_fd_sc_hd__decap_3
Xplace381 _3442_/A VGND VGND VPWR VPWR _4466_/A sky130_fd_sc_hd__buf_2
Xplace370 _3556_/A VGND VGND VPWR VPWR _4188_/C1 sky130_fd_sc_hd__buf_2
X_6805_ _7404_/CLK _6805_/D VGND VGND VPWR VPWR _6805_/Q sky130_fd_sc_hd__dfxtp_2
XFILLER_23_278 VGND VGND VPWR VPWR sky130_fd_sc_hd__fill_2
XFILLER_51_598 VGND VGND VPWR VPWR sky130_fd_sc_hd__fill_2
Xplace392 _4671_/B VGND VGND VPWR VPWR _5633_/B sky130_fd_sc_hd__buf_2
X_6736_ _6967_/CLK _6736_/D VGND VGND VPWR VPWR _6736_/Q sky130_fd_sc_hd__dfxtp_2
X_4997_ _4997_/A1 _6992_/D _4983_/X _4996_/X VGND VGND VPWR VPWR _4997_/X sky130_fd_sc_hd__a211o_2
XFILLER_109_328 VGND VGND VPWR VPWR sky130_fd_sc_hd__decap_3
X_6667_ _6672_/A VGND VGND VPWR VPWR _6667_/Y sky130_fd_sc_hd__inv_2
X_3879_ _6747_/Q _3890_/A2 _3889_/A2 _6735_/Q _3878_/X VGND VGND VPWR VPWR _3879_/X
+ sky130_fd_sc_hd__a221o_2
X_6598_ _6599_/A VGND VGND VPWR VPWR _6598_/Y sky130_fd_sc_hd__inv_2
XFILLER_105_501 VGND VGND VPWR VPWR sky130_fd_sc_hd__decap_3
XFILLER_105_523 VGND VGND VPWR VPWR sky130_fd_sc_hd__decap_3
XFILLER_105_545 VGND VGND VPWR VPWR sky130_fd_sc_hd__decap_3
XFILLER_105_578 VGND VGND VPWR VPWR sky130_fd_sc_hd__decap_3
X_7219_ clkload2/A _7219_/D _6499_/Y VGND VGND VPWR VPWR _7219_/Q sky130_fd_sc_hd__dfrtp_2
XFILLER_48_67 VGND VGND VPWR VPWR sky130_fd_sc_hd__decap_3
XFILLER_59_665 VGND VGND VPWR VPWR sky130_fd_sc_hd__fill_2
XFILLER_86_451 VGND VGND VPWR VPWR sky130_fd_sc_hd__decap_3
XFILLER_46_315 VGND VGND VPWR VPWR sky130_fd_sc_hd__decap_3
XFILLER_58_153 VGND VGND VPWR VPWR sky130_fd_sc_hd__decap_3
XFILLER_74_613 VGND VGND VPWR VPWR sky130_fd_sc_hd__fill_2
XFILLER_0_19 VGND VGND VPWR VPWR sky130_fd_sc_hd__fill_1
XFILLER_104_62 VGND VGND VPWR VPWR sky130_fd_sc_hd__decap_3
XFILLER_46_348 VGND VGND VPWR VPWR sky130_fd_sc_hd__decap_3
XFILLER_58_186 VGND VGND VPWR VPWR sky130_fd_sc_hd__fill_1
XFILLER_58_197 VGND VGND VPWR VPWR sky130_fd_sc_hd__decap_3
XFILLER_74_635 VGND VGND VPWR VPWR sky130_fd_sc_hd__decap_3
XFILLER_104_95 VGND VGND VPWR VPWR sky130_fd_sc_hd__decap_3
XFILLER_27_540 VGND VGND VPWR VPWR sky130_fd_sc_hd__decap_3
XFILLER_61_318 VGND VGND VPWR VPWR sky130_fd_sc_hd__decap_3
XFILLER_73_156 VGND VGND VPWR VPWR sky130_fd_sc_hd__fill_2
XFILLER_73_167 VGND VGND VPWR VPWR sky130_fd_sc_hd__fill_1
XFILLER_27_573 VGND VGND VPWR VPWR sky130_fd_sc_hd__decap_3
XFILLER_42_510 VGND VGND VPWR VPWR sky130_fd_sc_hd__decap_3
XFILLER_64_66 VGND VGND VPWR VPWR sky130_fd_sc_hd__decap_3
XFILLER_73_178 VGND VGND VPWR VPWR sky130_fd_sc_hd__decap_3
XTAP_TAPCELL_ROW_64_1024 VGND VPWR sky130_fd_sc_hd__tapvpwrvgnd_1
XFILLER_14_234 VGND VGND VPWR VPWR sky130_fd_sc_hd__decap_3
XFILLER_14_256 VGND VGND VPWR VPWR sky130_fd_sc_hd__decap_3
XFILLER_42_554 VGND VGND VPWR VPWR sky130_fd_sc_hd__fill_2
XFILLER_80_21 VGND VGND VPWR VPWR sky130_fd_sc_hd__decap_3
XFILLER_80_32 VGND VGND VPWR VPWR sky130_fd_sc_hd__decap_3
XFILLER_9_28 VGND VGND VPWR VPWR sky130_fd_sc_hd__decap_3
XFILLER_80_65 VGND VGND VPWR VPWR sky130_fd_sc_hd__decap_3
Xfanout60 _6587_/A VGND VGND VPWR VPWR _6616_/A sky130_fd_sc_hd__buf_2
Xfanout71 fanout72/X VGND VGND VPWR VPWR _6275_/A sky130_fd_sc_hd__buf_1
XTAP_TAPCELL_ROW_40_733 VGND VPWR sky130_fd_sc_hd__tapvpwrvgnd_1
XFILLER_50_9 VGND VGND VPWR VPWR sky130_fd_sc_hd__decap_3
XFILLER_89_52 VGND VGND VPWR VPWR sky130_fd_sc_hd__decap_3
XTAP_TAPCELL_ROW_20_490 VGND VPWR sky130_fd_sc_hd__tapvpwrvgnd_1
XFILLER_89_63 VGND VGND VPWR VPWR sky130_fd_sc_hd__decap_3
XTAP_TAPCELL_ROW_75_1153 VGND VPWR sky130_fd_sc_hd__tapvpwrvgnd_1
XFILLER_89_96 VGND VGND VPWR VPWR sky130_fd_sc_hd__decap_3
XFILLER_69_429 VGND VGND VPWR VPWR sky130_fd_sc_hd__decap_3
XFILLER_96_215 VGND VGND VPWR VPWR sky130_fd_sc_hd__decap_3
XFILLER_1_193 VGND VGND VPWR VPWR sky130_fd_sc_hd__decap_3
XFILLER_49_131 VGND VGND VPWR VPWR sky130_fd_sc_hd__decap_3
XFILLER_49_164 VGND VGND VPWR VPWR sky130_fd_sc_hd__decap_3
XFILLER_49_175 VGND VGND VPWR VPWR sky130_fd_sc_hd__decap_3
XFILLER_65_602 VGND VGND VPWR VPWR sky130_fd_sc_hd__decap_3
XFILLER_65_613 VGND VGND VPWR VPWR sky130_fd_sc_hd__decap_3
XFILLER_77_484 VGND VGND VPWR VPWR sky130_fd_sc_hd__decap_3
XFILLER_92_410 VGND VGND VPWR VPWR sky130_fd_sc_hd__decap_3
XFILLER_37_337 VGND VGND VPWR VPWR sky130_fd_sc_hd__decap_3
XFILLER_64_123 VGND VGND VPWR VPWR sky130_fd_sc_hd__decap_3
XFILLER_65_646 VGND VGND VPWR VPWR sky130_fd_sc_hd__fill_1
XFILLER_92_421 VGND VGND VPWR VPWR sky130_fd_sc_hd__decap_3
XTAP_TAPCELL_ROW_48_833 VGND VPWR sky130_fd_sc_hd__tapvpwrvgnd_1
XTAP_TAPCELL_ROW_48_822 VGND VPWR sky130_fd_sc_hd__tapvpwrvgnd_1
XFILLER_52_318 VGND VGND VPWR VPWR sky130_fd_sc_hd__decap_3
XFILLER_64_178 VGND VGND VPWR VPWR sky130_fd_sc_hd__fill_1
XFILLER_80_638 VGND VGND VPWR VPWR sky130_fd_sc_hd__decap_3
XFILLER_92_498 VGND VGND VPWR VPWR sky130_fd_sc_hd__decap_3
X_4920_ _4920_/A _4920_/B VGND VGND VPWR VPWR _4920_/Y sky130_fd_sc_hd__xnor2_2
XTAP_TAPCELL_ROW_86_1282 VGND VPWR sky130_fd_sc_hd__tapvpwrvgnd_1
XFILLER_60_340 VGND VGND VPWR VPWR sky130_fd_sc_hd__decap_3
X_4851_ _4633_/A _4142_/X _4849_/Y _4850_/Y _4969_/B VGND VGND VPWR VPWR _4855_/B
+ sky130_fd_sc_hd__o311a_2
XTAP_TAPCELL_ROW_28_590 VGND VPWR sky130_fd_sc_hd__tapvpwrvgnd_1
XFILLER_60_373 VGND VGND VPWR VPWR sky130_fd_sc_hd__decap_3
X_3802_ _3733_/X _3794_/X _3796_/X _3746_/X _3801_/X VGND VGND VPWR VPWR _3802_/X
+ sky130_fd_sc_hd__a221o_2
X_4782_ _4413_/A _4444_/X _4780_/Y _4969_/B VGND VGND VPWR VPWR _4782_/Y sky130_fd_sc_hd__o31ai_2
XPHY_EDGE_ROW_72_Left_189 VGND VGND VPWR VPWR sky130_fd_sc_hd__decap_3
XFILLER_20_259 VGND VGND VPWR VPWR sky130_fd_sc_hd__decap_3
X_6521_ _6587_/A VGND VGND VPWR VPWR _6521_/Y sky130_fd_sc_hd__inv_2
X_3733_ _3746_/A _3741_/B _3733_/C VGND VGND VPWR VPWR _3733_/X sky130_fd_sc_hd__and3_2
XFILLER_109_29 VGND VGND VPWR VPWR sky130_fd_sc_hd__fill_2
X_6452_ _6610_/A VGND VGND VPWR VPWR _6452_/Y sky130_fd_sc_hd__inv_2
XFILLER_106_309 VGND VGND VPWR VPWR sky130_fd_sc_hd__decap_3
Xclkload30 _7368_/CLK VGND VGND VPWR VPWR clkload30/X sky130_fd_sc_hd__clkbuf_16
X_6383_ _6548_/A VGND VGND VPWR VPWR _6383_/Y sky130_fd_sc_hd__inv_2
X_3595_ _4292_/A _3594_/B _3594_/Y _5020_/A VGND VGND VPWR VPWR _3614_/A sky130_fd_sc_hd__a211o_2
XFILLER_114_397 VGND VGND VPWR VPWR sky130_fd_sc_hd__decap_3
XFILLER_87_215 VGND VGND VPWR VPWR sky130_fd_sc_hd__decap_3
XPHY_EDGE_ROW_81_Left_198 VGND VGND VPWR VPWR sky130_fd_sc_hd__decap_3
XFILLER_102_548 VGND VGND VPWR VPWR sky130_fd_sc_hd__decap_3
X_7004_ _7404_/CLK _7004_/D _6284_/Y VGND VGND VPWR VPWR _7004_/Q sky130_fd_sc_hd__dfrtp_2
X_5196_ _5196_/A _5217_/B VGND VGND VPWR VPWR _7230_/D sky130_fd_sc_hd__and2_2
X_4216_ _7068_/Q _4265_/B _4205_/A VGND VGND VPWR VPWR _4371_/B sky130_fd_sc_hd__o21a_2
XFILLER_18_26 VGND VGND VPWR VPWR sky130_fd_sc_hd__fill_2
XFILLER_56_624 VGND VGND VPWR VPWR sky130_fd_sc_hd__decap_3
X_4147_ _7266_/Q _4418_/A2 _3956_/S _7330_/Q _4146_/X VGND VGND VPWR VPWR _4147_/X
+ sky130_fd_sc_hd__a221o_2
XFILLER_55_123 VGND VGND VPWR VPWR sky130_fd_sc_hd__decap_3
XFILLER_95_270 VGND VGND VPWR VPWR sky130_fd_sc_hd__decap_3
XFILLER_28_359 VGND VGND VPWR VPWR sky130_fd_sc_hd__decap_3
XFILLER_83_465 VGND VGND VPWR VPWR sky130_fd_sc_hd__decap_3
XFILLER_83_476 VGND VGND VPWR VPWR sky130_fd_sc_hd__decap_3
X_4078_ _7025_/Q _4437_/A2 _4435_/B1 _7371_/Q VGND VGND VPWR VPWR _4078_/X sky130_fd_sc_hd__a22o_2
XFILLER_55_189 VGND VGND VPWR VPWR sky130_fd_sc_hd__decap_3
XFILLER_64_690 VGND VGND VPWR VPWR sky130_fd_sc_hd__fill_2
XFILLER_71_638 VGND VGND VPWR VPWR sky130_fd_sc_hd__decap_3
XFILLER_36_392 VGND VGND VPWR VPWR sky130_fd_sc_hd__decap_3
XFILLER_70_137 VGND VGND VPWR VPWR sky130_fd_sc_hd__decap_3
XFILLER_11_204 VGND VGND VPWR VPWR sky130_fd_sc_hd__decap_3
XFILLER_11_237 VGND VGND VPWR VPWR sky130_fd_sc_hd__decap_3
XFILLER_7_208 VGND VGND VPWR VPWR sky130_fd_sc_hd__decap_3
Xclkload2 clkload2/A VGND VGND VPWR VPWR clkload2/X sky130_fd_sc_hd__clkbuf_8
X_6719_ _6976_/CLK _6719_/D VGND VGND VPWR VPWR _6719_/Q sky130_fd_sc_hd__dfxtp_2
XFILLER_50_46 VGND VGND VPWR VPWR sky130_fd_sc_hd__decap_3
XFILLER_50_79 VGND VGND VPWR VPWR sky130_fd_sc_hd__decap_3
XFILLER_105_353 VGND VGND VPWR VPWR sky130_fd_sc_hd__decap_3
XFILLER_59_33 VGND VGND VPWR VPWR sky130_fd_sc_hd__decap_3
XFILLER_59_55 VGND VGND VPWR VPWR sky130_fd_sc_hd__fill_1
XFILLER_59_66 VGND VGND VPWR VPWR sky130_fd_sc_hd__fill_2
XFILLER_59_77 VGND VGND VPWR VPWR sky130_fd_sc_hd__decap_3
XFILLER_78_237 VGND VGND VPWR VPWR sky130_fd_sc_hd__fill_2
XFILLER_47_613 VGND VGND VPWR VPWR sky130_fd_sc_hd__decap_3
XFILLER_59_462 VGND VGND VPWR VPWR sky130_fd_sc_hd__decap_3
XFILLER_75_21 VGND VGND VPWR VPWR sky130_fd_sc_hd__decap_3
XFILLER_115_83 VGND VGND VPWR VPWR sky130_fd_sc_hd__fill_2
XFILLER_19_326 VGND VGND VPWR VPWR sky130_fd_sc_hd__decap_3
XFILLER_19_337 VGND VGND VPWR VPWR sky130_fd_sc_hd__decap_3
XFILLER_59_495 VGND VGND VPWR VPWR sky130_fd_sc_hd__decap_3
XFILLER_74_421 VGND VGND VPWR VPWR sky130_fd_sc_hd__decap_3
XFILLER_75_43 VGND VGND VPWR VPWR sky130_fd_sc_hd__decap_3
XFILLER_86_270 VGND VGND VPWR VPWR sky130_fd_sc_hd__decap_3
XTAP_TAPCELL_ROW_70_1094 VGND VPWR sky130_fd_sc_hd__tapvpwrvgnd_1
XFILLER_34_307 VGND VGND VPWR VPWR sky130_fd_sc_hd__fill_1
XFILLER_46_156 VGND VGND VPWR VPWR sky130_fd_sc_hd__decap_3
XFILLER_74_443 VGND VGND VPWR VPWR sky130_fd_sc_hd__decap_3
XTAP_TAPCELL_ROW_109_1558 VGND VPWR sky130_fd_sc_hd__tapvpwrvgnd_1
XFILLER_27_370 VGND VGND VPWR VPWR sky130_fd_sc_hd__decap_3
XFILLER_55_690 VGND VGND VPWR VPWR sky130_fd_sc_hd__fill_2
XFILLER_61_137 VGND VGND VPWR VPWR sky130_fd_sc_hd__decap_3
XFILLER_91_31 VGND VGND VPWR VPWR sky130_fd_sc_hd__decap_3
XFILLER_42_373 VGND VGND VPWR VPWR sky130_fd_sc_hd__decap_3
XFILLER_91_75 VGND VGND VPWR VPWR sky130_fd_sc_hd__decap_3
XTAP_TAPCELL_ROW_53_891 VGND VPWR sky130_fd_sc_hd__tapvpwrvgnd_1
XFILLER_10_281 VGND VGND VPWR VPWR sky130_fd_sc_hd__decap_3
XFILLER_116_629 VGND VGND VPWR VPWR sky130_fd_sc_hd__fill_1
Xhold709 _6798_/Q VGND VGND VPWR VPWR _6798_/D sky130_fd_sc_hd__dlygate4sd3_1
XFILLER_6_263 VGND VGND VPWR VPWR sky130_fd_sc_hd__decap_3
XFILLER_108_191 VGND VGND VPWR VPWR sky130_fd_sc_hd__decap_3
X_3380_ _3528_/A _5118_/D VGND VGND VPWR VPWR _3380_/Y sky130_fd_sc_hd__nor2_2
XFILLER_97_535 VGND VGND VPWR VPWR sky130_fd_sc_hd__decap_3
XFILLER_69_237 VGND VGND VPWR VPWR sky130_fd_sc_hd__decap_3
XFILLER_97_557 VGND VGND VPWR VPWR sky130_fd_sc_hd__decap_3
X_5050_ _5086_/A _5101_/B _5100_/B _4366_/X VGND VGND VPWR VPWR _5050_/X sky130_fd_sc_hd__a31o_2
XFILLER_27_3 VGND VGND VPWR VPWR sky130_fd_sc_hd__decap_3
XFILLER_38_624 VGND VGND VPWR VPWR sky130_fd_sc_hd__fill_2
XFILLER_65_432 VGND VGND VPWR VPWR sky130_fd_sc_hd__decap_3
XFILLER_77_281 VGND VGND VPWR VPWR sky130_fd_sc_hd__fill_2
XFILLER_77_292 VGND VGND VPWR VPWR sky130_fd_sc_hd__decap_3
XTAP_TAPCELL_ROW_88_1311 VGND VPWR sky130_fd_sc_hd__tapvpwrvgnd_1
XFILLER_37_134 VGND VGND VPWR VPWR sky130_fd_sc_hd__decap_3
XFILLER_53_605 VGND VGND VPWR VPWR sky130_fd_sc_hd__decap_3
XFILLER_1_84 VGND VGND VPWR VPWR sky130_fd_sc_hd__decap_3
XFILLER_25_329 VGND VGND VPWR VPWR sky130_fd_sc_hd__decap_3
XFILLER_37_167 VGND VGND VPWR VPWR sky130_fd_sc_hd__fill_1
XFILLER_37_178 VGND VGND VPWR VPWR sky130_fd_sc_hd__decap_3
XFILLER_65_476 VGND VGND VPWR VPWR sky130_fd_sc_hd__decap_3
XFILLER_80_424 VGND VGND VPWR VPWR sky130_fd_sc_hd__decap_3
XFILLER_18_381 VGND VGND VPWR VPWR sky130_fd_sc_hd__decap_3
XFILLER_52_137 VGND VGND VPWR VPWR sky130_fd_sc_hd__decap_3
XFILLER_52_159 VGND VGND VPWR VPWR sky130_fd_sc_hd__decap_3
XFILLER_80_468 VGND VGND VPWR VPWR sky130_fd_sc_hd__fill_2
XFILLER_92_295 VGND VGND VPWR VPWR sky130_fd_sc_hd__decap_3
X_4903_ _4903_/A _4903_/B _4903_/C VGND VGND VPWR VPWR _4903_/X sky130_fd_sc_hd__and3_2
XFILLER_33_340 VGND VGND VPWR VPWR sky130_fd_sc_hd__decap_3
XFILLER_60_170 VGND VGND VPWR VPWR sky130_fd_sc_hd__decap_3
X_4834_ _4834_/A _4834_/B VGND VGND VPWR VPWR _4834_/Y sky130_fd_sc_hd__nor2_2
X_4765_ _4765_/A _4765_/B VGND VGND VPWR VPWR _4766_/A sky130_fd_sc_hd__and2_2
X_6504_ _6570_/A VGND VGND VPWR VPWR _6504_/Y sky130_fd_sc_hd__inv_2
XTAP_TAPCELL_ROW_99_1440 VGND VPWR sky130_fd_sc_hd__tapvpwrvgnd_1
X_4696_ _5118_/C _4696_/B VGND VGND VPWR VPWR _5670_/B sky130_fd_sc_hd__nor2_2
XFILLER_20_38 VGND VGND VPWR VPWR sky130_fd_sc_hd__decap_3
X_6435_ _6599_/A VGND VGND VPWR VPWR _6435_/Y sky130_fd_sc_hd__inv_2
XFILLER_115_662 VGND VGND VPWR VPWR sky130_fd_sc_hd__decap_3
X_6366_ _6366_/A VGND VGND VPWR VPWR _6366_/Y sky130_fd_sc_hd__inv_2
X_3578_ _7284_/Q _5136_/S _3417_/X _7092_/Q VGND VGND VPWR VPWR _3583_/A sky130_fd_sc_hd__a22o_2
XFILLER_102_312 VGND VGND VPWR VPWR sky130_fd_sc_hd__decap_3
XFILLER_115_673 VGND VGND VPWR VPWR sky130_fd_sc_hd__decap_3
XFILLER_88_513 VGND VGND VPWR VPWR sky130_fd_sc_hd__decap_3
X_5317_ _5317_/A0 _4899_/X _5327_/S VGND VGND VPWR VPWR _7172_/D sky130_fd_sc_hd__mux2_2
XFILLER_102_345 VGND VGND VPWR VPWR sky130_fd_sc_hd__decap_3
XFILLER_29_14 VGND VGND VPWR VPWR sky130_fd_sc_hd__decap_3
X_6297_ _6548_/A VGND VGND VPWR VPWR _6297_/Y sky130_fd_sc_hd__inv_2
XFILLER_102_378 VGND VGND VPWR VPWR sky130_fd_sc_hd__decap_3
XFILLER_29_47 VGND VGND VPWR VPWR sky130_fd_sc_hd__decap_3
XFILLER_29_69 VGND VGND VPWR VPWR sky130_fd_sc_hd__decap_3
XFILLER_56_421 VGND VGND VPWR VPWR sky130_fd_sc_hd__decap_3
X_5179_ _5179_/A _5194_/B VGND VGND VPWR VPWR _7238_/D sky130_fd_sc_hd__and2_2
XFILLER_28_134 VGND VGND VPWR VPWR sky130_fd_sc_hd__decap_3
XFILLER_28_156 VGND VGND VPWR VPWR sky130_fd_sc_hd__decap_3
XFILLER_56_443 VGND VGND VPWR VPWR sky130_fd_sc_hd__fill_1
XFILLER_83_240 VGND VGND VPWR VPWR sky130_fd_sc_hd__decap_3
XFILLER_16_307 VGND VGND VPWR VPWR sky130_fd_sc_hd__fill_1
XFILLER_28_189 VGND VGND VPWR VPWR sky130_fd_sc_hd__decap_3
XFILLER_44_649 VGND VGND VPWR VPWR sky130_fd_sc_hd__fill_1
XFILLER_56_498 VGND VGND VPWR VPWR sky130_fd_sc_hd__decap_3
XFILLER_83_284 VGND VGND VPWR VPWR sky130_fd_sc_hd__decap_3
XTAP_TAPCELL_ROW_3_288 VGND VPWR sky130_fd_sc_hd__tapvpwrvgnd_1
XFILLER_45_57 VGND VGND VPWR VPWR sky130_fd_sc_hd__decap_3
XFILLER_45_79 VGND VGND VPWR VPWR sky130_fd_sc_hd__decap_3
XFILLER_71_435 VGND VGND VPWR VPWR sky130_fd_sc_hd__decap_3
XFILLER_101_52 VGND VGND VPWR VPWR sky130_fd_sc_hd__decap_3
XFILLER_52_671 VGND VGND VPWR VPWR sky130_fd_sc_hd__decap_3
XFILLER_101_63 VGND VGND VPWR VPWR sky130_fd_sc_hd__decap_3
XFILLER_61_12 VGND VGND VPWR VPWR sky130_fd_sc_hd__decap_3
XTAP_TAPCELL_ROW_104_1499 VGND VPWR sky130_fd_sc_hd__tapvpwrvgnd_1
XTAP_TAPCELL_ROW_50_850 VGND VPWR sky130_fd_sc_hd__tapvpwrvgnd_1
XFILLER_6_29 VGND VGND VPWR VPWR sky130_fd_sc_hd__decap_3
XFILLER_106_640 VGND VGND VPWR VPWR sky130_fd_sc_hd__decap_3
XFILLER_106_651 VGND VGND VPWR VPWR sky130_fd_sc_hd__decap_3
XFILLER_3_222 VGND VGND VPWR VPWR sky130_fd_sc_hd__fill_2
XFILLER_79_513 VGND VGND VPWR VPWR sky130_fd_sc_hd__decap_3
XTAP_TAPCELL_ROW_72_1112 VGND VPWR sky130_fd_sc_hd__tapvpwrvgnd_1
XFILLER_105_172 VGND VGND VPWR VPWR sky130_fd_sc_hd__decap_3
XFILLER_3_299 VGND VGND VPWR VPWR sky130_fd_sc_hd__decap_3
XFILLER_79_568 VGND VGND VPWR VPWR sky130_fd_sc_hd__decap_3
XFILLER_86_20 VGND VGND VPWR VPWR sky130_fd_sc_hd__decap_3
XFILLER_66_218 VGND VGND VPWR VPWR sky130_fd_sc_hd__decap_3
XFILLER_86_53 VGND VGND VPWR VPWR sky130_fd_sc_hd__decap_3
XFILLER_94_527 VGND VGND VPWR VPWR sky130_fd_sc_hd__decap_3
XFILLER_59_281 VGND VGND VPWR VPWR sky130_fd_sc_hd__decap_3
XFILLER_86_97 VGND VGND VPWR VPWR sky130_fd_sc_hd__decap_3
XFILLER_19_80 VGND VGND VPWR VPWR sky130_fd_sc_hd__decap_3
XFILLER_47_443 VGND VGND VPWR VPWR sky130_fd_sc_hd__decap_3
XTAP_TAPCELL_ROW_58_950 VGND VPWR sky130_fd_sc_hd__tapvpwrvgnd_1
XFILLER_19_167 VGND VGND VPWR VPWR sky130_fd_sc_hd__fill_1
XFILLER_19_178 VGND VGND VPWR VPWR sky130_fd_sc_hd__decap_3
XFILLER_19_189 VGND VGND VPWR VPWR sky130_fd_sc_hd__fill_1
XFILLER_62_424 VGND VGND VPWR VPWR sky130_fd_sc_hd__decap_3
XFILLER_34_126 VGND VGND VPWR VPWR sky130_fd_sc_hd__decap_3
XFILLER_62_457 VGND VGND VPWR VPWR sky130_fd_sc_hd__decap_3
XFILLER_15_340 VGND VGND VPWR VPWR sky130_fd_sc_hd__decap_3
XTAP_TAPCELL_ROW_83_1252 VGND VPWR sky130_fd_sc_hd__tapvpwrvgnd_1
XFILLER_35_90 VGND VGND VPWR VPWR sky130_fd_sc_hd__decap_3
XFILLER_30_365 VGND VGND VPWR VPWR sky130_fd_sc_hd__decap_3
XFILLER_30_398 VGND VGND VPWR VPWR sky130_fd_sc_hd__decap_3
X_4550_ _4550_/A _4569_/B VGND VGND VPWR VPWR _7305_/D sky130_fd_sc_hd__and2_2
XFILLER_7_561 VGND VGND VPWR VPWR sky130_fd_sc_hd__fill_2
X_3501_ _5144_/A _5144_/B _3500_/Y VGND VGND VPWR VPWR _3501_/X sky130_fd_sc_hd__a21o_2
X_3363_ _3386_/A _3561_/B _3362_/A VGND VGND VPWR VPWR _5294_/B sky130_fd_sc_hd__or3b_4
XTAP_TAPCELL_ROW_94_1381 VGND VPWR sky130_fd_sc_hd__tapvpwrvgnd_1
XFILLER_112_654 VGND VGND VPWR VPWR sky130_fd_sc_hd__decap_3
XFILLER_97_343 VGND VGND VPWR VPWR sky130_fd_sc_hd__fill_2
X_5102_ _5114_/A _4343_/X _5100_/Y _3618_/X _5101_/Y VGND VGND VPWR VPWR _5102_/X
+ sky130_fd_sc_hd__a221o_2
XFILLER_85_505 VGND VGND VPWR VPWR sky130_fd_sc_hd__fill_1
XFILLER_97_354 VGND VGND VPWR VPWR sky130_fd_sc_hd__decap_3
XFILLER_97_376 VGND VGND VPWR VPWR sky130_fd_sc_hd__decap_3
Xhold1206 _7131_/Q VGND VGND VPWR VPWR _5404_/A0 sky130_fd_sc_hd__dlygate4sd3_1
XFILLER_38_421 VGND VGND VPWR VPWR sky130_fd_sc_hd__decap_3
X_5033_ _5114_/A _4629_/Y _5032_/A _5033_/B2 VGND VGND VPWR VPWR _5033_/X sky130_fd_sc_hd__a22o_2
XFILLER_38_443 VGND VGND VPWR VPWR sky130_fd_sc_hd__decap_3
XFILLER_53_402 VGND VGND VPWR VPWR sky130_fd_sc_hd__decap_3
XFILLER_65_251 VGND VGND VPWR VPWR sky130_fd_sc_hd__decap_3
XFILLER_65_284 VGND VGND VPWR VPWR sky130_fd_sc_hd__decap_3
XTAP_TAPCELL_ROW_0_236 VGND VPWR sky130_fd_sc_hd__tapvpwrvgnd_1
XFILLER_53_435 VGND VGND VPWR VPWR sky130_fd_sc_hd__decap_3
XFILLER_65_295 VGND VGND VPWR VPWR sky130_fd_sc_hd__decap_3
XFILLER_80_210 VGND VGND VPWR VPWR sky130_fd_sc_hd__decap_3
XFILLER_80_243 VGND VGND VPWR VPWR sky130_fd_sc_hd__decap_3
X_6984_ _7364_/CLK _6984_/D _6264_/Y VGND VGND VPWR VPWR _6984_/Q sky130_fd_sc_hd__dfrtp_2
XTAP_TAPCELL_ROW_0_247 VGND VPWR sky130_fd_sc_hd__tapvpwrvgnd_1
XFILLER_80_265 VGND VGND VPWR VPWR sky130_fd_sc_hd__decap_3
XFILLER_21_310 VGND VGND VPWR VPWR sky130_fd_sc_hd__decap_3
XFILLER_33_181 VGND VGND VPWR VPWR sky130_fd_sc_hd__decap_3
XFILLER_80_298 VGND VGND VPWR VPWR sky130_fd_sc_hd__decap_3
XTAP_TAPCELL_ROW_36_688 VGND VPWR sky130_fd_sc_hd__tapvpwrvgnd_1
XFILLER_21_343 VGND VGND VPWR VPWR sky130_fd_sc_hd__decap_3
X_4817_ _4810_/X _4811_/X _4815_/X _4816_/X VGND VGND VPWR VPWR _5663_/B sky130_fd_sc_hd__a211o_2
XFILLER_21_365 VGND VGND VPWR VPWR sky130_fd_sc_hd__decap_3
XFILLER_31_37 VGND VGND VPWR VPWR sky130_fd_sc_hd__fill_1
X_4748_ _3683_/Y _5664_/B _3509_/B VGND VGND VPWR VPWR _4751_/A sky130_fd_sc_hd__a21o_2
XFILLER_107_426 VGND VGND VPWR VPWR sky130_fd_sc_hd__decap_3
X_4679_ _6990_/Q _5014_/B VGND VGND VPWR VPWR _5015_/B sky130_fd_sc_hd__nand2_2
X_6418_ _6578_/A VGND VGND VPWR VPWR _6418_/Y sky130_fd_sc_hd__inv_2
XPHY_EDGE_ROW_1_Right_1 VGND VGND VPWR VPWR sky130_fd_sc_hd__decap_3
XFILLER_0_203 VGND VGND VPWR VPWR sky130_fd_sc_hd__decap_3
X_7398_ _7406_/CLK _7398_/D _6678_/Y VGND VGND VPWR VPWR _7398_/Q sky130_fd_sc_hd__dfrtp_2
XFILLER_0_225 VGND VGND VPWR VPWR sky130_fd_sc_hd__decap_3
XFILLER_115_481 VGND VGND VPWR VPWR sky130_fd_sc_hd__fill_2
XFILLER_88_321 VGND VGND VPWR VPWR sky130_fd_sc_hd__decap_3
X_6349_ _6540_/A VGND VGND VPWR VPWR _6349_/Y sky130_fd_sc_hd__inv_2
XTAP_TAPCELL_ROW_8_347 VGND VPWR sky130_fd_sc_hd__tapvpwrvgnd_1
XFILLER_0_269 VGND VGND VPWR VPWR sky130_fd_sc_hd__decap_3
XFILLER_76_516 VGND VGND VPWR VPWR sky130_fd_sc_hd__decap_3
XFILLER_88_365 VGND VGND VPWR VPWR sky130_fd_sc_hd__decap_3
XFILLER_102_186 VGND VGND VPWR VPWR sky130_fd_sc_hd__decap_3
XFILLER_48_229 VGND VGND VPWR VPWR sky130_fd_sc_hd__decap_3
XFILLER_56_12 VGND VGND VPWR VPWR sky130_fd_sc_hd__fill_2
XFILLER_56_23 VGND VGND VPWR VPWR sky130_fd_sc_hd__decap_3
XFILLER_56_56 VGND VGND VPWR VPWR sky130_fd_sc_hd__decap_3
XFILLER_29_476 VGND VGND VPWR VPWR sky130_fd_sc_hd__decap_3
XFILLER_56_251 VGND VGND VPWR VPWR sky130_fd_sc_hd__fill_1
XFILLER_56_262 VGND VGND VPWR VPWR sky130_fd_sc_hd__decap_3
XFILLER_84_582 VGND VGND VPWR VPWR sky130_fd_sc_hd__decap_3
XFILLER_16_137 VGND VGND VPWR VPWR sky130_fd_sc_hd__decap_3
XFILLER_44_424 VGND VGND VPWR VPWR sky130_fd_sc_hd__decap_3
XFILLER_56_295 VGND VGND VPWR VPWR sky130_fd_sc_hd__decap_3
XTAP_TAPCELL_ROW_106_1528 VGND VPWR sky130_fd_sc_hd__tapvpwrvgnd_1
XFILLER_112_62 VGND VGND VPWR VPWR sky130_fd_sc_hd__decap_3
XFILLER_16_159 VGND VGND VPWR VPWR sky130_fd_sc_hd__decap_3
XFILLER_71_243 VGND VGND VPWR VPWR sky130_fd_sc_hd__decap_3
XFILLER_71_276 VGND VGND VPWR VPWR sky130_fd_sc_hd__decap_3
XFILLER_72_44 VGND VGND VPWR VPWR sky130_fd_sc_hd__decap_3
XFILLER_12_321 VGND VGND VPWR VPWR sky130_fd_sc_hd__decap_3
XFILLER_24_192 VGND VGND VPWR VPWR sky130_fd_sc_hd__decap_3
XFILLER_72_88 VGND VGND VPWR VPWR sky130_fd_sc_hd__decap_3
XFILLER_12_365 VGND VGND VPWR VPWR sky130_fd_sc_hd__decap_3
XFILLER_8_336 VGND VGND VPWR VPWR sky130_fd_sc_hd__fill_1
XFILLER_8_358 VGND VGND VPWR VPWR sky130_fd_sc_hd__decap_3
XFILLER_21_92 VGND VGND VPWR VPWR sky130_fd_sc_hd__decap_3
XFILLER_4_586 VGND VGND VPWR VPWR sky130_fd_sc_hd__fill_2
XFILLER_97_30 VGND VGND VPWR VPWR sky130_fd_sc_hd__decap_3
XFILLER_98_107 VGND VGND VPWR VPWR sky130_fd_sc_hd__decap_3
XFILLER_97_74 VGND VGND VPWR VPWR sky130_fd_sc_hd__decap_3
XFILLER_67_505 VGND VGND VPWR VPWR sky130_fd_sc_hd__decap_3
XFILLER_94_302 VGND VGND VPWR VPWR sky130_fd_sc_hd__decap_3
XFILLER_39_218 VGND VGND VPWR VPWR sky130_fd_sc_hd__decap_3
XFILLER_67_538 VGND VGND VPWR VPWR sky130_fd_sc_hd__decap_3
XFILLER_79_387 VGND VGND VPWR VPWR sky130_fd_sc_hd__decap_3
XFILLER_94_324 VGND VGND VPWR VPWR sky130_fd_sc_hd__decap_3
XFILLER_11_6 VGND VGND VPWR VPWR sky130_fd_sc_hd__fill_1
XFILLER_47_240 VGND VGND VPWR VPWR sky130_fd_sc_hd__decap_3
XFILLER_75_582 VGND VGND VPWR VPWR sky130_fd_sc_hd__decap_3
XFILLER_94_379 VGND VGND VPWR VPWR sky130_fd_sc_hd__decap_3
XFILLER_62_210 VGND VGND VPWR VPWR sky130_fd_sc_hd__decap_3
XFILLER_50_416 VGND VGND VPWR VPWR sky130_fd_sc_hd__decap_3
XFILLER_62_243 VGND VGND VPWR VPWR sky130_fd_sc_hd__decap_3
XFILLER_90_574 VGND VGND VPWR VPWR sky130_fd_sc_hd__fill_2
X_3981_ _7350_/Q _7318_/Q _3989_/S VGND VGND VPWR VPWR _7350_/D sky130_fd_sc_hd__mux2_2
XFILLER_16_682 VGND VGND VPWR VPWR sky130_fd_sc_hd__fill_2
XFILLER_50_438 VGND VGND VPWR VPWR sky130_fd_sc_hd__decap_3
XFILLER_62_287 VGND VGND VPWR VPWR sky130_fd_sc_hd__decap_3
XFILLER_15_181 VGND VGND VPWR VPWR sky130_fd_sc_hd__decap_3
XFILLER_31_663 VGND VGND VPWR VPWR sky130_fd_sc_hd__fill_1
XFILLER_94_3 VGND VGND VPWR VPWR sky130_fd_sc_hd__fill_1
Xclkbuf_leaf_42_clk clkbuf_leaf_1_clk/A VGND VGND VPWR VPWR clkload7/A sky130_fd_sc_hd__clkbuf_16
XTAP_TAPCELL_ROW_61_978 VGND VPWR sky130_fd_sc_hd__tapvpwrvgnd_1
XTAP_TAPCELL_ROW_33_647 VGND VPWR sky130_fd_sc_hd__tapvpwrvgnd_1
XFILLER_30_162 VGND VGND VPWR VPWR sky130_fd_sc_hd__decap_3
X_5651_ _5651_/A VGND VGND VPWR VPWR _5651_/Y sky130_fd_sc_hd__inv_2
XTAP_TAPCELL_ROW_61_989 VGND VPWR sky130_fd_sc_hd__tapvpwrvgnd_1
XFILLER_30_195 VGND VGND VPWR VPWR sky130_fd_sc_hd__fill_1
X_7321_ _7360_/CLK _7321_/D _6601_/Y VGND VGND VPWR VPWR _7321_/Q sky130_fd_sc_hd__dfrtp_2
XFILLER_116_234 VGND VGND VPWR VPWR sky130_fd_sc_hd__decap_3
X_7252_ clkload4/A _7252_/D _6532_/Y VGND VGND VPWR VPWR _7252_/Q sky130_fd_sc_hd__dfrtp_2
XFILLER_116_256 VGND VGND VPWR VPWR sky130_fd_sc_hd__decap_3
XFILLER_116_278 VGND VGND VPWR VPWR sky130_fd_sc_hd__fill_2
XFILLER_116_289 VGND VGND VPWR VPWR sky130_fd_sc_hd__decap_3
X_4464_ _3541_/X _3610_/B _4463_/X VGND VGND VPWR VPWR _5655_/C sky130_fd_sc_hd__o21ai_2
X_7183_ _7381_/CLK _7183_/D _6463_/Y VGND VGND VPWR VPWR _7183_/Q sky130_fd_sc_hd__dfrtp_2
X_4395_ _4396_/A _4444_/B VGND VGND VPWR VPWR _4397_/A sky130_fd_sc_hd__and2_2
X_3415_ _3449_/B _3449_/C _3417_/C VGND VGND VPWR VPWR _5136_/S sky130_fd_sc_hd__and3_4
XFILLER_58_516 VGND VGND VPWR VPWR sky130_fd_sc_hd__decap_3
X_3346_ _3346_/A VGND VGND VPWR VPWR _3509_/B sky130_fd_sc_hd__inv_2
XTAP_TAPCELL_ROW_5_317 VGND VPWR sky130_fd_sc_hd__tapvpwrvgnd_1
XTAP_TAPCELL_ROW_5_306 VGND VPWR sky130_fd_sc_hd__tapvpwrvgnd_1
XFILLER_85_313 VGND VGND VPWR VPWR sky130_fd_sc_hd__decap_3
Xhold1003 _7203_/Q VGND VGND VPWR VPWR _5253_/A0 sky130_fd_sc_hd__dlygate4sd3_1
Xhold1014 _7259_/Q VGND VGND VPWR VPWR _5041_/A0 sky130_fd_sc_hd__dlygate4sd3_1
XFILLER_100_668 VGND VGND VPWR VPWR sky130_fd_sc_hd__decap_3
XFILLER_73_508 VGND VGND VPWR VPWR sky130_fd_sc_hd__decap_3
Xhold1025 _7272_/Q VGND VGND VPWR VPWR _4823_/A0 sky130_fd_sc_hd__dlygate4sd3_1
Xhold1036 _7205_/Q VGND VGND VPWR VPWR _5249_/A0 sky130_fd_sc_hd__dlygate4sd3_1
Xhold1047 _7238_/Q VGND VGND VPWR VPWR _5179_/A sky130_fd_sc_hd__dlygate4sd3_1
Xhold1058 _7206_/Q VGND VGND VPWR VPWR _5247_/A0 sky130_fd_sc_hd__dlygate4sd3_1
X_5016_ _5032_/A _5031_/B _4629_/Y VGND VGND VPWR VPWR _5017_/B sky130_fd_sc_hd__a21oi_2
XFILLER_26_15 VGND VGND VPWR VPWR sky130_fd_sc_hd__decap_3
XFILLER_26_413 VGND VGND VPWR VPWR sky130_fd_sc_hd__decap_3
XFILLER_38_251 VGND VGND VPWR VPWR sky130_fd_sc_hd__fill_1
XFILLER_38_262 VGND VGND VPWR VPWR sky130_fd_sc_hd__decap_3
Xhold1069 _4474_/X VGND VGND VPWR VPWR _7342_/D sky130_fd_sc_hd__dlygate4sd3_1
XFILLER_26_446 VGND VGND VPWR VPWR sky130_fd_sc_hd__fill_1
XFILLER_53_210 VGND VGND VPWR VPWR sky130_fd_sc_hd__decap_3
XFILLER_81_541 VGND VGND VPWR VPWR sky130_fd_sc_hd__decap_3
XFILLER_53_265 VGND VGND VPWR VPWR sky130_fd_sc_hd__decap_3
X_6967_ _6967_/CLK _6967_/D VGND VGND VPWR VPWR _6967_/Q sky130_fd_sc_hd__dfxtp_2
XFILLER_13_107 VGND VGND VPWR VPWR sky130_fd_sc_hd__decap_3
XFILLER_41_416 VGND VGND VPWR VPWR sky130_fd_sc_hd__decap_3
XFILLER_53_287 VGND VGND VPWR VPWR sky130_fd_sc_hd__decap_3
Xclkbuf_leaf_33_clk clkbuf_3_2__f_clk/X VGND VGND VPWR VPWR _6967_/CLK sky130_fd_sc_hd__clkbuf_16
X_6898_ _6909_/CLK _6898_/D VGND VGND VPWR VPWR _6898_/Q sky130_fd_sc_hd__dfxtp_2
XFILLER_21_151 VGND VGND VPWR VPWR sky130_fd_sc_hd__decap_3
XTAP_TAPCELL_ROW_101_1469 VGND VPWR sky130_fd_sc_hd__tapvpwrvgnd_1
XTAP_TAPCELL_ROW_101_1458 VGND VPWR sky130_fd_sc_hd__tapvpwrvgnd_1
XFILLER_21_184 VGND VGND VPWR VPWR sky130_fd_sc_hd__decap_3
XFILLER_5_317 VGND VGND VPWR VPWR sky130_fd_sc_hd__decap_3
XFILLER_107_223 VGND VGND VPWR VPWR sky130_fd_sc_hd__fill_1
XFILLER_107_234 VGND VGND VPWR VPWR sky130_fd_sc_hd__decap_3
XFILLER_107_278 VGND VGND VPWR VPWR sky130_fd_sc_hd__fill_2
XFILLER_1_534 VGND VGND VPWR VPWR sky130_fd_sc_hd__decap_3
XFILLER_89_641 VGND VGND VPWR VPWR sky130_fd_sc_hd__decap_3
Xhold870 _7115_/Q VGND VGND VPWR VPWR _7115_/D sky130_fd_sc_hd__dlygate4sd3_1
Xhold881 _7067_/Q VGND VGND VPWR VPWR _7067_/D sky130_fd_sc_hd__dlygate4sd3_1
XFILLER_103_440 VGND VGND VPWR VPWR sky130_fd_sc_hd__decap_3
XFILLER_49_505 VGND VGND VPWR VPWR sky130_fd_sc_hd__fill_1
Xhold892 _7060_/Q VGND VGND VPWR VPWR _7060_/D sky130_fd_sc_hd__dlygate4sd3_1
XFILLER_67_44 VGND VGND VPWR VPWR sky130_fd_sc_hd__decap_3
XFILLER_88_162 VGND VGND VPWR VPWR sky130_fd_sc_hd__decap_3
XFILLER_88_184 VGND VGND VPWR VPWR sky130_fd_sc_hd__decap_3
XFILLER_89_685 VGND VGND VPWR VPWR sky130_fd_sc_hd__decap_3
XTAP_TAPCELL_ROW_112_1598 VGND VPWR sky130_fd_sc_hd__tapvpwrvgnd_1
XFILLER_67_99 VGND VGND VPWR VPWR sky130_fd_sc_hd__decap_3
XFILLER_76_368 VGND VGND VPWR VPWR sky130_fd_sc_hd__decap_3
XFILLER_29_251 VGND VGND VPWR VPWR sky130_fd_sc_hd__decap_3
XFILLER_57_582 VGND VGND VPWR VPWR sky130_fd_sc_hd__fill_1
XFILLER_64_519 VGND VGND VPWR VPWR sky130_fd_sc_hd__decap_3
XFILLER_17_446 VGND VGND VPWR VPWR sky130_fd_sc_hd__fill_2
XFILLER_44_221 VGND VGND VPWR VPWR sky130_fd_sc_hd__decap_3
XFILLER_83_32 VGND VGND VPWR VPWR sky130_fd_sc_hd__decap_3
XFILLER_83_43 VGND VGND VPWR VPWR sky130_fd_sc_hd__decap_3
XFILLER_44_265 VGND VGND VPWR VPWR sky130_fd_sc_hd__decap_3
XFILLER_83_54 VGND VGND VPWR VPWR sky130_fd_sc_hd__fill_2
XTAP_TAPCELL_ROW_67_1055 VGND VPWR sky130_fd_sc_hd__tapvpwrvgnd_1
XFILLER_83_98 VGND VGND VPWR VPWR sky130_fd_sc_hd__decap_3
XTAP_TAPCELL_ROW_80_1211 VGND VPWR sky130_fd_sc_hd__tapvpwrvgnd_1
XFILLER_16_81 VGND VGND VPWR VPWR sky130_fd_sc_hd__decap_3
Xclkbuf_leaf_24_clk clkbuf_3_6__f_clk/X VGND VGND VPWR VPWR _7198_/CLK sky130_fd_sc_hd__clkbuf_16
XFILLER_40_471 VGND VGND VPWR VPWR sky130_fd_sc_hd__decap_3
XFILLER_80_9 VGND VGND VPWR VPWR sky130_fd_sc_hd__fill_2
XFILLER_8_100 VGND VGND VPWR VPWR sky130_fd_sc_hd__decap_3
XTAP_TAPCELL_ROW_30_617 VGND VPWR sky130_fd_sc_hd__tapvpwrvgnd_1
XTAP_TAPCELL_ROW_30_606 VGND VPWR sky130_fd_sc_hd__tapvpwrvgnd_1
XFILLER_12_195 VGND VGND VPWR VPWR sky130_fd_sc_hd__fill_1
XFILLER_8_144 VGND VGND VPWR VPWR sky130_fd_sc_hd__decap_3
XFILLER_8_177 VGND VGND VPWR VPWR sky130_fd_sc_hd__decap_3
XTAP_TAPCELL_ROW_10_374 VGND VPWR sky130_fd_sc_hd__tapvpwrvgnd_1
XFILLER_113_204 VGND VGND VPWR VPWR sky130_fd_sc_hd__decap_3
XTAP_TAPCELL_ROW_78_1184 VGND VPWR sky130_fd_sc_hd__tapvpwrvgnd_1
XFILLER_113_237 VGND VGND VPWR VPWR sky130_fd_sc_hd__fill_2
XFILLER_4_394 VGND VGND VPWR VPWR sky130_fd_sc_hd__decap_3
XTAP_TAPCELL_ROW_91_1340 VGND VPWR sky130_fd_sc_hd__tapvpwrvgnd_1
XFILLER_99_449 VGND VGND VPWR VPWR sky130_fd_sc_hd__decap_3
XFILLER_99_438 VGND VGND VPWR VPWR sky130_fd_sc_hd__decap_3
XFILLER_79_140 VGND VGND VPWR VPWR sky130_fd_sc_hd__decap_3
X_4180_ _7232_/Q _4414_/A2 _4507_/S _7045_/Q VGND VGND VPWR VPWR _4180_/X sky130_fd_sc_hd__a22o_2
XFILLER_67_346 VGND VGND VPWR VPWR sky130_fd_sc_hd__decap_3
XTAP_TAPCELL_ROW_38_706 VGND VPWR sky130_fd_sc_hd__tapvpwrvgnd_1
XFILLER_35_210 VGND VGND VPWR VPWR sky130_fd_sc_hd__decap_3
XFILLER_48_582 VGND VGND VPWR VPWR sky130_fd_sc_hd__decap_3
XFILLER_82_349 VGND VGND VPWR VPWR sky130_fd_sc_hd__decap_3
XFILLER_23_405 VGND VGND VPWR VPWR sky130_fd_sc_hd__decap_3
XFILLER_35_254 VGND VGND VPWR VPWR sky130_fd_sc_hd__decap_3
XFILLER_63_552 VGND VGND VPWR VPWR sky130_fd_sc_hd__decap_3
X_6821_ _6976_/CLK _6821_/D VGND VGND VPWR VPWR _6821_/Q sky130_fd_sc_hd__dfxtp_2
XFILLER_35_276 VGND VGND VPWR VPWR sky130_fd_sc_hd__decap_3
XFILLER_63_596 VGND VGND VPWR VPWR sky130_fd_sc_hd__fill_2
XFILLER_90_360 VGND VGND VPWR VPWR sky130_fd_sc_hd__decap_3
XFILLER_90_371 VGND VGND VPWR VPWR sky130_fd_sc_hd__decap_3
XFILLER_90_393 VGND VGND VPWR VPWR sky130_fd_sc_hd__decap_3
XTAP_TAPCELL_ROW_18_463 VGND VPWR sky130_fd_sc_hd__tapvpwrvgnd_1
XFILLER_23_449 VGND VGND VPWR VPWR sky130_fd_sc_hd__decap_3
XFILLER_50_235 VGND VGND VPWR VPWR sky130_fd_sc_hd__decap_3
Xclkbuf_leaf_15_clk clkload0/A VGND VGND VPWR VPWR _7340_/CLK sky130_fd_sc_hd__clkbuf_16
X_6752_ _6929_/CLK _6752_/D VGND VGND VPWR VPWR _6752_/Q sky130_fd_sc_hd__dfxtp_2
X_3964_ _7358_/Q _3964_/A1 _3964_/S VGND VGND VPWR VPWR _7358_/D sky130_fd_sc_hd__mux2_2
XFILLER_50_279 VGND VGND VPWR VPWR sky130_fd_sc_hd__decap_3
X_6683_ _6683_/A VGND VGND VPWR VPWR _6683_/Y sky130_fd_sc_hd__inv_2
X_5703_ _7357_/Q hold928/X _5706_/S VGND VGND VPWR VPWR _6701_/D sky130_fd_sc_hd__mux2_2
X_3895_ _3682_/A _3887_/X _3889_/X _3741_/X _3894_/X VGND VGND VPWR VPWR _3895_/X
+ sky130_fd_sc_hd__a221o_2
X_5634_ _5634_/A _5634_/B VGND VGND VPWR VPWR _7011_/D sky130_fd_sc_hd__and2_2
X_7304_ _7365_/CLK _7304_/D _6584_/Y VGND VGND VPWR VPWR _7304_/Q sky130_fd_sc_hd__dfrtp_2
XFILLER_2_309 VGND VGND VPWR VPWR sky130_fd_sc_hd__decap_3
XFILLER_104_237 VGND VGND VPWR VPWR sky130_fd_sc_hd__decap_3
X_7235_ _7363_/CLK _7235_/D _6515_/Y VGND VGND VPWR VPWR _7235_/Q sky130_fd_sc_hd__dfrtp_2
X_4447_ _4447_/A _4447_/B VGND VGND VPWR VPWR _4447_/Y sky130_fd_sc_hd__nor2_2
X_7166_ _7294_/CLK _7166_/D _6446_/Y VGND VGND VPWR VPWR _7166_/Q sky130_fd_sc_hd__dfrtp_2
XFILLER_100_410 VGND VGND VPWR VPWR sky130_fd_sc_hd__decap_3
XFILLER_86_633 VGND VGND VPWR VPWR sky130_fd_sc_hd__fill_2
X_4378_ _4243_/Y _4277_/Y _5032_/B _4377_/Y VGND VGND VPWR VPWR _4968_/A sky130_fd_sc_hd__a31o_4
XFILLER_98_471 VGND VGND VPWR VPWR sky130_fd_sc_hd__decap_3
XFILLER_100_421 VGND VGND VPWR VPWR sky130_fd_sc_hd__decap_3
XFILLER_112_292 VGND VGND VPWR VPWR sky130_fd_sc_hd__decap_3
XFILLER_58_335 VGND VGND VPWR VPWR sky130_fd_sc_hd__decap_3
XFILLER_85_121 VGND VGND VPWR VPWR sky130_fd_sc_hd__decap_3
X_7097_ clkload6/A _7097_/D _6377_/Y VGND VGND VPWR VPWR _7097_/Q sky130_fd_sc_hd__dfrtp_2
X_3329_ _6982_/Q _3340_/C VGND VGND VPWR VPWR _3329_/Y sky130_fd_sc_hd__nand2_2
XFILLER_100_454 VGND VGND VPWR VPWR sky130_fd_sc_hd__decap_3
XFILLER_100_465 VGND VGND VPWR VPWR sky130_fd_sc_hd__decap_3
XFILLER_46_519 VGND VGND VPWR VPWR sky130_fd_sc_hd__decap_3
XFILLER_58_368 VGND VGND VPWR VPWR sky130_fd_sc_hd__fill_1
XFILLER_73_316 VGND VGND VPWR VPWR sky130_fd_sc_hd__decap_3
XFILLER_66_390 VGND VGND VPWR VPWR sky130_fd_sc_hd__decap_3
XFILLER_73_349 VGND VGND VPWR VPWR sky130_fd_sc_hd__decap_3
XFILLER_26_243 VGND VGND VPWR VPWR sky130_fd_sc_hd__decap_3
XFILLER_26_287 VGND VGND VPWR VPWR sky130_fd_sc_hd__decap_3
XFILLER_53_24 VGND VGND VPWR VPWR sky130_fd_sc_hd__decap_3
XFILLER_81_382 VGND VGND VPWR VPWR sky130_fd_sc_hd__decap_3
XFILLER_41_235 VGND VGND VPWR VPWR sky130_fd_sc_hd__decap_3
XFILLER_53_57 VGND VGND VPWR VPWR sky130_fd_sc_hd__decap_3
XFILLER_81_393 VGND VGND VPWR VPWR sky130_fd_sc_hd__decap_3
XFILLER_41_268 VGND VGND VPWR VPWR sky130_fd_sc_hd__decap_3
XFILLER_10_666 VGND VGND VPWR VPWR sky130_fd_sc_hd__fill_1
XFILLER_5_158 VGND VGND VPWR VPWR sky130_fd_sc_hd__decap_3
XFILLER_5_169 VGND VGND VPWR VPWR sky130_fd_sc_hd__decap_3
XTAP_TAPCELL_ROW_114_1616 VGND VPWR sky130_fd_sc_hd__tapvpwrvgnd_1
XFILLER_108_598 VGND VGND VPWR VPWR sky130_fd_sc_hd__decap_3
XFILLER_78_43 VGND VGND VPWR VPWR sky130_fd_sc_hd__decap_3
XFILLER_49_324 VGND VGND VPWR VPWR sky130_fd_sc_hd__decap_3
XFILLER_89_482 VGND VGND VPWR VPWR sky130_fd_sc_hd__decap_3
XFILLER_103_281 VGND VGND VPWR VPWR sky130_fd_sc_hd__decap_3
XFILLER_49_346 VGND VGND VPWR VPWR sky130_fd_sc_hd__decap_3
XFILLER_37_508 VGND VGND VPWR VPWR sky130_fd_sc_hd__decap_3
XFILLER_49_379 VGND VGND VPWR VPWR sky130_fd_sc_hd__fill_1
XFILLER_64_305 VGND VGND VPWR VPWR sky130_fd_sc_hd__decap_3
XFILLER_76_165 VGND VGND VPWR VPWR sky130_fd_sc_hd__decap_3
XFILLER_92_625 VGND VGND VPWR VPWR sky130_fd_sc_hd__decap_3
XFILLER_45_530 VGND VGND VPWR VPWR sky130_fd_sc_hd__fill_2
XFILLER_64_327 VGND VGND VPWR VPWR sky130_fd_sc_hd__decap_3
XFILLER_64_338 VGND VGND VPWR VPWR sky130_fd_sc_hd__decap_3
XFILLER_91_113 VGND VGND VPWR VPWR sky130_fd_sc_hd__decap_3
XFILLER_92_658 VGND VGND VPWR VPWR sky130_fd_sc_hd__fill_1
XFILLER_17_254 VGND VGND VPWR VPWR sky130_fd_sc_hd__decap_3
XFILLER_94_97 VGND VGND VPWR VPWR sky130_fd_sc_hd__fill_2
XFILLER_32_213 VGND VGND VPWR VPWR sky130_fd_sc_hd__decap_3
XFILLER_72_360 VGND VGND VPWR VPWR sky130_fd_sc_hd__decap_3
XFILLER_72_371 VGND VGND VPWR VPWR sky130_fd_sc_hd__decap_3
XFILLER_60_533 VGND VGND VPWR VPWR sky130_fd_sc_hd__decap_3
XTAP_TAPCELL_ROW_15_433 VGND VPWR sky130_fd_sc_hd__tapvpwrvgnd_1
XTAP_TAPCELL_ROW_43_764 VGND VPWR sky130_fd_sc_hd__tapvpwrvgnd_1
X_3680_ _3677_/Y _3828_/A2 _3827_/B1 _3679_/Y VGND VGND VPWR VPWR _3680_/X sky130_fd_sc_hd__a22o_2
X_5350_ _5350_/A0 _5131_/X _5350_/S VGND VGND VPWR VPWR _7156_/D sky130_fd_sc_hd__mux2_2
XFILLER_114_513 VGND VGND VPWR VPWR sky130_fd_sc_hd__decap_3
XFILLER_114_524 VGND VGND VPWR VPWR sky130_fd_sc_hd__fill_2
X_4301_ _7352_/Q _4338_/B1 _4339_/B1 _7160_/Q _4300_/X VGND VGND VPWR VPWR _4301_/X
+ sky130_fd_sc_hd__a221o_2
XFILLER_4_191 VGND VGND VPWR VPWR sky130_fd_sc_hd__decap_3
XFILLER_4_51 VGND VGND VPWR VPWR sky130_fd_sc_hd__decap_3
X_7020_ _7361_/CLK _7020_/D _6300_/Y VGND VGND VPWR VPWR _7020_/Q sky130_fd_sc_hd__dfrtp_2
X_4232_ _4228_/X _4231_/X _4327_/A VGND VGND VPWR VPWR _4628_/A sky130_fd_sc_hd__o21a_2
XFILLER_99_246 VGND VGND VPWR VPWR sky130_fd_sc_hd__decap_3
XFILLER_101_207 VGND VGND VPWR VPWR sky130_fd_sc_hd__decap_3
Xclkbuf_leaf_4_clk clkbuf_leaf_7_clk/A VGND VGND VPWR VPWR _7330_/CLK sky130_fd_sc_hd__clkbuf_16
XFILLER_99_279 VGND VGND VPWR VPWR sky130_fd_sc_hd__fill_1
XFILLER_95_441 VGND VGND VPWR VPWR sky130_fd_sc_hd__decap_3
X_4163_ _7073_/Q _4265_/B _4205_/A VGND VGND VPWR VPWR _4203_/B sky130_fd_sc_hd__o21a_2
XFILLER_67_165 VGND VGND VPWR VPWR sky130_fd_sc_hd__decap_3
XFILLER_83_603 VGND VGND VPWR VPWR sky130_fd_sc_hd__decap_3
XFILLER_83_614 VGND VGND VPWR VPWR sky130_fd_sc_hd__fill_2
XFILLER_95_485 VGND VGND VPWR VPWR sky130_fd_sc_hd__decap_3
X_4094_ _4095_/A _4210_/B VGND VGND VPWR VPWR _4096_/A sky130_fd_sc_hd__or2_2
XFILLER_55_327 VGND VGND VPWR VPWR sky130_fd_sc_hd__decap_3
XFILLER_55_349 VGND VGND VPWR VPWR sky130_fd_sc_hd__decap_3
XFILLER_83_658 VGND VGND VPWR VPWR sky130_fd_sc_hd__decap_3
XFILLER_82_168 VGND VGND VPWR VPWR sky130_fd_sc_hd__decap_3
XFILLER_51_500 VGND VGND VPWR VPWR sky130_fd_sc_hd__decap_3
XFILLER_63_382 VGND VGND VPWR VPWR sky130_fd_sc_hd__decap_3
XFILLER_63_393 VGND VGND VPWR VPWR sky130_fd_sc_hd__decap_3
Xplace382 _4190_/B1 VGND VGND VPWR VPWR _5229_/C sky130_fd_sc_hd__buf_2
Xplace371 _4799_/A VGND VGND VPWR VPWR _4832_/A sky130_fd_sc_hd__buf_2
Xplace360 _5159_/S VGND VGND VPWR VPWR _5080_/S sky130_fd_sc_hd__buf_2
X_6804_ _7404_/CLK _6804_/D VGND VGND VPWR VPWR _6804_/Q sky130_fd_sc_hd__dfxtp_2
X_4996_ _4799_/A _5657_/D _3817_/X _3346_/A VGND VGND VPWR VPWR _4996_/X sky130_fd_sc_hd__o211a_2
XFILLER_23_27 VGND VGND VPWR VPWR sky130_fd_sc_hd__decap_3
Xplace393 _5666_/A VGND VGND VPWR VPWR _4997_/A1 sky130_fd_sc_hd__buf_2
X_6735_ _6976_/CLK _6735_/D VGND VGND VPWR VPWR _6735_/Q sky130_fd_sc_hd__dfxtp_2
X_3947_ _7366_/Q _4491_/A0 _3947_/S VGND VGND VPWR VPWR _7366_/D sky130_fd_sc_hd__mux2_2
XFILLER_109_307 VGND VGND VPWR VPWR sky130_fd_sc_hd__decap_3
X_6666_ _6670_/A VGND VGND VPWR VPWR _6666_/Y sky130_fd_sc_hd__inv_2
X_3878_ _6729_/Q _3889_/B1 _3888_/B1 _6741_/Q VGND VGND VPWR VPWR _3878_/X sky130_fd_sc_hd__a22o_2
X_6597_ _6635_/A VGND VGND VPWR VPWR _6597_/Y sky130_fd_sc_hd__inv_2
X_5617_ _5617_/A _5634_/B VGND VGND VPWR VPWR _7019_/D sky130_fd_sc_hd__and2_2
XFILLER_2_106 VGND VGND VPWR VPWR sky130_fd_sc_hd__fill_1
XFILLER_2_117 VGND VGND VPWR VPWR sky130_fd_sc_hd__decap_3
XFILLER_105_557 VGND VGND VPWR VPWR sky130_fd_sc_hd__decap_3
XFILLER_2_139 VGND VGND VPWR VPWR sky130_fd_sc_hd__fill_1
X_7218_ clkload3/A _7218_/D _6498_/Y VGND VGND VPWR VPWR _7218_/Q sky130_fd_sc_hd__dfrtp_2
XFILLER_48_35 VGND VGND VPWR VPWR sky130_fd_sc_hd__decap_3
XFILLER_86_430 VGND VGND VPWR VPWR sky130_fd_sc_hd__decap_3
X_7149_ _7340_/CLK _7149_/D _6429_/Y VGND VGND VPWR VPWR _7149_/Q sky130_fd_sc_hd__dfrtp_2
XFILLER_100_240 VGND VGND VPWR VPWR sky130_fd_sc_hd__decap_3
XFILLER_100_262 VGND VGND VPWR VPWR sky130_fd_sc_hd__decap_3
XFILLER_58_165 VGND VGND VPWR VPWR sky130_fd_sc_hd__decap_3
XFILLER_100_295 VGND VGND VPWR VPWR sky130_fd_sc_hd__decap_3
XFILLER_104_41 VGND VGND VPWR VPWR sky130_fd_sc_hd__fill_1
XFILLER_46_327 VGND VGND VPWR VPWR sky130_fd_sc_hd__decap_3
XFILLER_64_12 VGND VGND VPWR VPWR sky130_fd_sc_hd__decap_3
XFILLER_73_102 VGND VGND VPWR VPWR sky130_fd_sc_hd__decap_3
XFILLER_73_135 VGND VGND VPWR VPWR sky130_fd_sc_hd__decap_3
XPHY_EDGE_ROW_100_Left_217 VGND VGND VPWR VPWR sky130_fd_sc_hd__decap_3
XFILLER_104_74 VGND VGND VPWR VPWR sky130_fd_sc_hd__decap_3
XFILLER_39_390 VGND VGND VPWR VPWR sky130_fd_sc_hd__fill_2
XFILLER_27_596 VGND VGND VPWR VPWR sky130_fd_sc_hd__fill_2
XFILLER_54_382 VGND VGND VPWR VPWR sky130_fd_sc_hd__decap_3
XFILLER_64_56 VGND VGND VPWR VPWR sky130_fd_sc_hd__decap_3
XFILLER_64_78 VGND VGND VPWR VPWR sky130_fd_sc_hd__fill_1
XFILLER_82_680 VGND VGND VPWR VPWR sky130_fd_sc_hd__decap_3
XFILLER_82_691 VGND VGND VPWR VPWR sky130_fd_sc_hd__fill_1
XTAP_TAPCELL_ROW_64_1014 VGND VPWR sky130_fd_sc_hd__tapvpwrvgnd_1
XFILLER_14_246 VGND VGND VPWR VPWR sky130_fd_sc_hd__decap_3
XFILLER_42_533 VGND VGND VPWR VPWR sky130_fd_sc_hd__decap_3
XFILLER_81_190 VGND VGND VPWR VPWR sky130_fd_sc_hd__fill_1
XTAP_TAPCELL_ROW_64_1025 VGND VPWR sky130_fd_sc_hd__tapvpwrvgnd_1
XFILLER_80_44 VGND VGND VPWR VPWR sky130_fd_sc_hd__decap_3
Xfanout50 wire582/X VGND VGND VPWR VPWR _6388_/A sky130_fd_sc_hd__buf_2
Xfanout61 _6587_/A VGND VGND VPWR VPWR _6584_/A sky130_fd_sc_hd__buf_2
Xfanout72 _6652_/A VGND VGND VPWR VPWR fanout72/X sky130_fd_sc_hd__clkdlybuf4s25_1
XTAP_TAPCELL_ROW_40_734 VGND VPWR sky130_fd_sc_hd__tapvpwrvgnd_1
XFILLER_10_441 VGND VGND VPWR VPWR sky130_fd_sc_hd__fill_2
XFILLER_13_60 VGND VGND VPWR VPWR sky130_fd_sc_hd__decap_3
XFILLER_22_290 VGND VGND VPWR VPWR sky130_fd_sc_hd__decap_3
XFILLER_80_88 VGND VGND VPWR VPWR sky130_fd_sc_hd__decap_3
XFILLER_10_474 VGND VGND VPWR VPWR sky130_fd_sc_hd__fill_2
XFILLER_13_82 VGND VGND VPWR VPWR sky130_fd_sc_hd__decap_3
XFILLER_6_434 VGND VGND VPWR VPWR sky130_fd_sc_hd__fill_1
XFILLER_89_31 VGND VGND VPWR VPWR sky130_fd_sc_hd__decap_3
XTAP_TAPCELL_ROW_20_491 VGND VPWR sky130_fd_sc_hd__tapvpwrvgnd_1
XFILLER_108_395 VGND VGND VPWR VPWR sky130_fd_sc_hd__fill_1
XFILLER_89_75 VGND VGND VPWR VPWR sky130_fd_sc_hd__decap_3
XFILLER_69_408 VGND VGND VPWR VPWR sky130_fd_sc_hd__decap_3
XTAP_TAPCELL_ROW_75_1154 VGND VPWR sky130_fd_sc_hd__tapvpwrvgnd_1
XFILLER_111_505 VGND VGND VPWR VPWR sky130_fd_sc_hd__decap_3
XFILLER_96_227 VGND VGND VPWR VPWR sky130_fd_sc_hd__decap_3
XFILLER_77_441 VGND VGND VPWR VPWR sky130_fd_sc_hd__decap_3
XFILLER_96_249 VGND VGND VPWR VPWR sky130_fd_sc_hd__decap_3
XFILLER_37_305 VGND VGND VPWR VPWR sky130_fd_sc_hd__decap_3
XFILLER_49_143 VGND VGND VPWR VPWR sky130_fd_sc_hd__decap_3
XFILLER_77_463 VGND VGND VPWR VPWR sky130_fd_sc_hd__decap_3
XFILLER_49_187 VGND VGND VPWR VPWR sky130_fd_sc_hd__fill_1
XFILLER_65_625 VGND VGND VPWR VPWR sky130_fd_sc_hd__decap_3
XFILLER_65_658 VGND VGND VPWR VPWR sky130_fd_sc_hd__decap_3
XTAP_TAPCELL_ROW_48_823 VGND VPWR sky130_fd_sc_hd__tapvpwrvgnd_1
XFILLER_18_541 VGND VGND VPWR VPWR sky130_fd_sc_hd__fill_1
XFILLER_64_135 VGND VGND VPWR VPWR sky130_fd_sc_hd__decap_3
XFILLER_92_455 VGND VGND VPWR VPWR sky130_fd_sc_hd__decap_3
XFILLER_92_477 VGND VGND VPWR VPWR sky130_fd_sc_hd__decap_3
Xclkbuf_3_7__f_clk clkbuf_0_clk/X VGND VGND VPWR VPWR clkload0/A sky130_fd_sc_hd__clkbuf_16
XFILLER_33_500 VGND VGND VPWR VPWR sky130_fd_sc_hd__decap_3
XFILLER_33_533 VGND VGND VPWR VPWR sky130_fd_sc_hd__fill_2
XFILLER_45_393 VGND VGND VPWR VPWR sky130_fd_sc_hd__decap_3
X_4850_ _4142_/X _4849_/Y _4633_/A VGND VGND VPWR VPWR _4850_/Y sky130_fd_sc_hd__o21ai_2
XTAP_TAPCELL_ROW_86_1283 VGND VPWR sky130_fd_sc_hd__tapvpwrvgnd_1
XTAP_TAPCELL_ROW_28_591 VGND VPWR sky130_fd_sc_hd__tapvpwrvgnd_1
XFILLER_33_577 VGND VGND VPWR VPWR sky130_fd_sc_hd__decap_3
XFILLER_60_352 VGND VGND VPWR VPWR sky130_fd_sc_hd__decap_3
X_3801_ _3735_/X _3798_/X _3800_/X _3714_/X VGND VGND VPWR VPWR _3801_/X sky130_fd_sc_hd__a22o_2
XFILLER_60_385 VGND VGND VPWR VPWR sky130_fd_sc_hd__decap_3
X_6520_ _6616_/A VGND VGND VPWR VPWR _6520_/Y sky130_fd_sc_hd__inv_2
X_4781_ _4444_/X _4780_/Y _4413_/A VGND VGND VPWR VPWR _4781_/X sky130_fd_sc_hd__o21a_2
X_3732_ _6776_/Q _3869_/A2 _3825_/B1 _6764_/Q _3731_/X VGND VGND VPWR VPWR _3732_/X
+ sky130_fd_sc_hd__a221o_2
XFILLER_9_261 VGND VGND VPWR VPWR sky130_fd_sc_hd__decap_3
Xclkload20 _7294_/CLK VGND VGND VPWR VPWR clkload20/Y sky130_fd_sc_hd__bufinv_16
X_6451_ _6522_/A VGND VGND VPWR VPWR _6451_/Y sky130_fd_sc_hd__inv_2
XFILLER_9_294 VGND VGND VPWR VPWR sky130_fd_sc_hd__decap_3
Xclkload31 _7406_/CLK VGND VGND VPWR VPWR clkload31/Y sky130_fd_sc_hd__clkinv_4
X_6382_ _6539_/A VGND VGND VPWR VPWR _6382_/Y sky130_fd_sc_hd__inv_2
X_5402_ _5402_/A0 _5027_/X _5429_/S VGND VGND VPWR VPWR _7132_/D sky130_fd_sc_hd__mux2_2
X_5333_ _5333_/A0 _5027_/X _5340_/S VGND VGND VPWR VPWR _7164_/D sky130_fd_sc_hd__mux2_2
X_3594_ _4292_/A _3594_/B VGND VGND VPWR VPWR _3594_/Y sky130_fd_sc_hd__nor2_2
XFILLER_102_505 VGND VGND VPWR VPWR sky130_fd_sc_hd__decap_3
XFILLER_114_365 VGND VGND VPWR VPWR sky130_fd_sc_hd__decap_3
X_5264_ _5264_/A0 _4997_/X _5274_/S VGND VGND VPWR VPWR _7198_/D sky130_fd_sc_hd__mux2_2
XFILLER_87_238 VGND VGND VPWR VPWR sky130_fd_sc_hd__decap_3
X_7003_ _7404_/CLK _7003_/D _6283_/Y VGND VGND VPWR VPWR _7003_/Q sky130_fd_sc_hd__dfrtp_2
X_4215_ _7260_/Q _4356_/A2 _4212_/X _4214_/X VGND VGND VPWR VPWR _4371_/A sky130_fd_sc_hd__a211o_2
XFILLER_110_560 VGND VGND VPWR VPWR sky130_fd_sc_hd__decap_3
X_4146_ _7234_/Q _4349_/B1 _4190_/B1 _7138_/Q VGND VGND VPWR VPWR _4146_/X sky130_fd_sc_hd__a22o_2
XFILLER_18_38 VGND VGND VPWR VPWR sky130_fd_sc_hd__decap_3
XFILLER_18_49 VGND VGND VPWR VPWR sky130_fd_sc_hd__decap_3
XFILLER_28_327 VGND VGND VPWR VPWR sky130_fd_sc_hd__decap_3
XFILLER_55_113 VGND VGND VPWR VPWR sky130_fd_sc_hd__fill_2
XFILLER_43_308 VGND VGND VPWR VPWR sky130_fd_sc_hd__decap_3
XFILLER_55_135 VGND VGND VPWR VPWR sky130_fd_sc_hd__decap_3
XFILLER_55_157 VGND VGND VPWR VPWR sky130_fd_sc_hd__decap_3
XFILLER_71_617 VGND VGND VPWR VPWR sky130_fd_sc_hd__decap_3
X_4077_ _7243_/Q _4433_/B _4434_/A2 _7115_/Q _4076_/X VGND VGND VPWR VPWR _4077_/X
+ sky130_fd_sc_hd__a221o_2
XFILLER_70_105 VGND VGND VPWR VPWR sky130_fd_sc_hd__decap_3
XFILLER_24_533 VGND VGND VPWR VPWR sky130_fd_sc_hd__decap_3
XFILLER_51_363 VGND VGND VPWR VPWR sky130_fd_sc_hd__decap_3
XFILLER_51_374 VGND VGND VPWR VPWR sky130_fd_sc_hd__decap_3
XFILLER_51_396 VGND VGND VPWR VPWR sky130_fd_sc_hd__decap_3
X_4979_ _4979_/A0 _4978_/X _5028_/S VGND VGND VPWR VPWR _7263_/D sky130_fd_sc_hd__mux2_2
XFILLER_11_249 VGND VGND VPWR VPWR sky130_fd_sc_hd__decap_3
Xclkload3 clkload3/A VGND VGND VPWR VPWR clkload3/Y sky130_fd_sc_hd__inv_4
X_6718_ _7198_/CLK _6718_/D VGND VGND VPWR VPWR _6718_/Q sky130_fd_sc_hd__dfxtp_2
XFILLER_50_25 VGND VGND VPWR VPWR sky130_fd_sc_hd__decap_3
XFILLER_50_58 VGND VGND VPWR VPWR sky130_fd_sc_hd__decap_3
X_6649_ _6651_/A VGND VGND VPWR VPWR _6649_/Y sky130_fd_sc_hd__inv_2
XFILLER_105_321 VGND VGND VPWR VPWR sky130_fd_sc_hd__decap_3
XFILLER_105_343 VGND VGND VPWR VPWR sky130_fd_sc_hd__fill_1
XFILLER_19_305 VGND VGND VPWR VPWR sky130_fd_sc_hd__decap_3
XFILLER_59_441 VGND VGND VPWR VPWR sky130_fd_sc_hd__decap_3
XFILLER_59_452 VGND VGND VPWR VPWR sky130_fd_sc_hd__fill_2
XFILLER_101_593 VGND VGND VPWR VPWR sky130_fd_sc_hd__decap_3
XFILLER_46_102 VGND VGND VPWR VPWR sky130_fd_sc_hd__decap_3
XFILLER_46_124 VGND VGND VPWR VPWR sky130_fd_sc_hd__decap_3
XFILLER_75_55 VGND VGND VPWR VPWR sky130_fd_sc_hd__fill_1
XFILLER_86_282 VGND VGND VPWR VPWR sky130_fd_sc_hd__decap_3
XTAP_TAPCELL_ROW_70_1095 VGND VPWR sky130_fd_sc_hd__tapvpwrvgnd_1
XFILLER_19_349 VGND VGND VPWR VPWR sky130_fd_sc_hd__fill_1
XFILLER_74_455 VGND VGND VPWR VPWR sky130_fd_sc_hd__decap_3
XFILLER_75_77 VGND VGND VPWR VPWR sky130_fd_sc_hd__decap_3
XTAP_TAPCELL_ROW_109_1559 VGND VPWR sky130_fd_sc_hd__tapvpwrvgnd_1
XFILLER_46_179 VGND VGND VPWR VPWR sky130_fd_sc_hd__decap_3
XFILLER_61_105 VGND VGND VPWR VPWR sky130_fd_sc_hd__decap_3
XFILLER_61_116 VGND VGND VPWR VPWR sky130_fd_sc_hd__decap_3
XFILLER_74_477 VGND VGND VPWR VPWR sky130_fd_sc_hd__decap_3
XFILLER_74_499 VGND VGND VPWR VPWR sky130_fd_sc_hd__decap_3
XFILLER_15_522 VGND VGND VPWR VPWR sky130_fd_sc_hd__fill_2
XFILLER_27_382 VGND VGND VPWR VPWR sky130_fd_sc_hd__fill_1
XFILLER_61_127 VGND VGND VPWR VPWR sky130_fd_sc_hd__decap_3
XFILLER_61_149 VGND VGND VPWR VPWR sky130_fd_sc_hd__decap_3
XFILLER_42_363 VGND VGND VPWR VPWR sky130_fd_sc_hd__fill_1
XTAP_TAPCELL_ROW_25_550 VGND VPWR sky130_fd_sc_hd__tapvpwrvgnd_1
XTAP_TAPCELL_ROW_53_892 VGND VPWR sky130_fd_sc_hd__tapvpwrvgnd_1
XFILLER_24_81 VGND VGND VPWR VPWR sky130_fd_sc_hd__decap_3
XFILLER_6_242 VGND VGND VPWR VPWR sky130_fd_sc_hd__decap_3
XFILLER_6_253 VGND VGND VPWR VPWR sky130_fd_sc_hd__fill_2
XFILLER_108_170 VGND VGND VPWR VPWR sky130_fd_sc_hd__decap_3
XFILLER_6_275 VGND VGND VPWR VPWR sky130_fd_sc_hd__decap_3
XFILLER_6_297 VGND VGND VPWR VPWR sky130_fd_sc_hd__decap_3
XFILLER_69_216 VGND VGND VPWR VPWR sky130_fd_sc_hd__decap_3
XFILLER_97_503 VGND VGND VPWR VPWR sky130_fd_sc_hd__fill_1
XFILLER_97_514 VGND VGND VPWR VPWR sky130_fd_sc_hd__decap_3
XFILLER_111_324 VGND VGND VPWR VPWR sky130_fd_sc_hd__decap_3
XFILLER_69_249 VGND VGND VPWR VPWR sky130_fd_sc_hd__decap_3
XFILLER_97_547 VGND VGND VPWR VPWR sky130_fd_sc_hd__fill_2
XFILLER_97_569 VGND VGND VPWR VPWR sky130_fd_sc_hd__fill_2
XFILLER_84_219 VGND VGND VPWR VPWR sky130_fd_sc_hd__decap_3
XFILLER_37_113 VGND VGND VPWR VPWR sky130_fd_sc_hd__decap_3
XFILLER_65_411 VGND VGND VPWR VPWR sky130_fd_sc_hd__decap_3
XTAP_TAPCELL_ROW_88_1312 VGND VPWR sky130_fd_sc_hd__tapvpwrvgnd_1
XFILLER_37_146 VGND VGND VPWR VPWR sky130_fd_sc_hd__fill_1
XFILLER_65_444 VGND VGND VPWR VPWR sky130_fd_sc_hd__decap_3
XFILLER_65_455 VGND VGND VPWR VPWR sky130_fd_sc_hd__fill_1
XFILLER_92_241 VGND VGND VPWR VPWR sky130_fd_sc_hd__fill_2
XFILLER_18_360 VGND VGND VPWR VPWR sky130_fd_sc_hd__decap_3
XFILLER_25_308 VGND VGND VPWR VPWR sky130_fd_sc_hd__decap_3
XFILLER_53_628 VGND VGND VPWR VPWR sky130_fd_sc_hd__decap_3
XFILLER_80_403 VGND VGND VPWR VPWR sky130_fd_sc_hd__decap_3
XFILLER_18_393 VGND VGND VPWR VPWR sky130_fd_sc_hd__decap_3
XFILLER_33_330 VGND VGND VPWR VPWR sky130_fd_sc_hd__decap_3
XFILLER_46_691 VGND VGND VPWR VPWR sky130_fd_sc_hd__fill_1
XFILLER_80_436 VGND VGND VPWR VPWR sky130_fd_sc_hd__decap_3
XFILLER_33_352 VGND VGND VPWR VPWR sky130_fd_sc_hd__decap_3
X_4833_ _7001_/Q _4687_/B _4983_/A VGND VGND VPWR VPWR _4834_/B sky130_fd_sc_hd__o21ai_2
X_4764_ _4938_/A _4764_/B VGND VGND VPWR VPWR _4788_/A sky130_fd_sc_hd__nor2_2
X_6503_ _6570_/A VGND VGND VPWR VPWR _6503_/Y sky130_fd_sc_hd__inv_2
XTAP_TAPCELL_ROW_99_1441 VGND VPWR sky130_fd_sc_hd__tapvpwrvgnd_1
X_6434_ _6570_/A VGND VGND VPWR VPWR _6434_/Y sky130_fd_sc_hd__inv_2
X_4695_ _7008_/Q _4728_/A _4694_/Y _5647_/A VGND VGND VPWR VPWR _4695_/X sky130_fd_sc_hd__a211o_2
XFILLER_106_107 VGND VGND VPWR VPWR sky130_fd_sc_hd__decap_3
XFILLER_20_17 VGND VGND VPWR VPWR sky130_fd_sc_hd__decap_3
X_6365_ _6366_/A VGND VGND VPWR VPWR _6365_/Y sky130_fd_sc_hd__inv_2
X_3577_ _7060_/Q _3577_/B VGND VGND VPWR VPWR _3591_/C sky130_fd_sc_hd__nor2_2
XFILLER_88_525 VGND VGND VPWR VPWR sky130_fd_sc_hd__decap_3
X_6296_ _6539_/A VGND VGND VPWR VPWR _6296_/Y sky130_fd_sc_hd__inv_2
XFILLER_102_324 VGND VGND VPWR VPWR sky130_fd_sc_hd__decap_3
XFILLER_29_26 VGND VGND VPWR VPWR sky130_fd_sc_hd__decap_3
XFILLER_88_536 VGND VGND VPWR VPWR sky130_fd_sc_hd__decap_3
X_5247_ _5247_/A0 _4864_/X _5262_/S VGND VGND VPWR VPWR _7206_/D sky130_fd_sc_hd__mux2_2
XFILLER_102_357 VGND VGND VPWR VPWR sky130_fd_sc_hd__decap_3
XFILLER_102_368 VGND VGND VPWR VPWR sky130_fd_sc_hd__fill_1
XFILLER_28_102 VGND VGND VPWR VPWR sky130_fd_sc_hd__decap_3
XFILLER_28_113 VGND VGND VPWR VPWR sky130_fd_sc_hd__decap_3
XFILLER_29_625 VGND VGND VPWR VPWR sky130_fd_sc_hd__fill_2
XFILLER_68_282 VGND VGND VPWR VPWR sky130_fd_sc_hd__decap_3
XFILLER_75_219 VGND VGND VPWR VPWR sky130_fd_sc_hd__decap_3
X_4129_ _7299_/Q _4501_/S _4196_/A2 _7363_/Q _4429_/C1 VGND VGND VPWR VPWR _4129_/X
+ sky130_fd_sc_hd__a221o_2
XFILLER_28_168 VGND VGND VPWR VPWR sky130_fd_sc_hd__fill_2
XFILLER_43_116 VGND VGND VPWR VPWR sky130_fd_sc_hd__decap_3
XFILLER_45_14 VGND VGND VPWR VPWR sky130_fd_sc_hd__decap_3
XFILLER_56_477 VGND VGND VPWR VPWR sky130_fd_sc_hd__decap_3
XFILLER_71_414 VGND VGND VPWR VPWR sky130_fd_sc_hd__fill_1
XFILLER_83_252 VGND VGND VPWR VPWR sky130_fd_sc_hd__decap_3
XTAP_TAPCELL_ROW_3_289 VGND VPWR sky130_fd_sc_hd__tapvpwrvgnd_1
XFILLER_71_458 VGND VGND VPWR VPWR sky130_fd_sc_hd__decap_3
XFILLER_101_20 VGND VGND VPWR VPWR sky130_fd_sc_hd__decap_3
XFILLER_101_75 VGND VGND VPWR VPWR sky130_fd_sc_hd__decap_3
XFILLER_24_374 VGND VGND VPWR VPWR sky130_fd_sc_hd__fill_2
XFILLER_24_385 VGND VGND VPWR VPWR sky130_fd_sc_hd__decap_3
XFILLER_51_160 VGND VGND VPWR VPWR sky130_fd_sc_hd__decap_3
XFILLER_51_182 VGND VGND VPWR VPWR sky130_fd_sc_hd__decap_3
XFILLER_61_24 VGND VGND VPWR VPWR sky130_fd_sc_hd__decap_3
XFILLER_61_57 VGND VGND VPWR VPWR sky130_fd_sc_hd__decap_3
XFILLER_8_507 VGND VGND VPWR VPWR sky130_fd_sc_hd__decap_3
XTAP_TAPCELL_ROW_50_851 VGND VPWR sky130_fd_sc_hd__tapvpwrvgnd_1
XTAP_TAPCELL_ROW_22_520 VGND VPWR sky130_fd_sc_hd__tapvpwrvgnd_1
XFILLER_6_19 VGND VGND VPWR VPWR sky130_fd_sc_hd__decap_3
XFILLER_3_201 VGND VGND VPWR VPWR sky130_fd_sc_hd__decap_3
XFILLER_10_72 VGND VGND VPWR VPWR sky130_fd_sc_hd__decap_3
XFILLER_3_267 VGND VGND VPWR VPWR sky130_fd_sc_hd__decap_3
XFILLER_79_525 VGND VGND VPWR VPWR sky130_fd_sc_hd__decap_3
XTAP_TAPCELL_ROW_72_1113 VGND VPWR sky130_fd_sc_hd__tapvpwrvgnd_1
XFILLER_105_184 VGND VGND VPWR VPWR sky130_fd_sc_hd__decap_3
XFILLER_10_83 VGND VGND VPWR VPWR sky130_fd_sc_hd__fill_1
XFILLER_86_32 VGND VGND VPWR VPWR sky130_fd_sc_hd__decap_3
XFILLER_86_65 VGND VGND VPWR VPWR sky130_fd_sc_hd__decap_3
XFILLER_94_506 VGND VGND VPWR VPWR sky130_fd_sc_hd__decap_3
XFILLER_47_411 VGND VGND VPWR VPWR sky130_fd_sc_hd__decap_3
XFILLER_94_539 VGND VGND VPWR VPWR sky130_fd_sc_hd__decap_3
XFILLER_101_390 VGND VGND VPWR VPWR sky130_fd_sc_hd__fill_2
XFILLER_47_455 VGND VGND VPWR VPWR sky130_fd_sc_hd__decap_3
XFILLER_59_293 VGND VGND VPWR VPWR sky130_fd_sc_hd__decap_3
XTAP_TAPCELL_ROW_58_951 VGND VPWR sky130_fd_sc_hd__tapvpwrvgnd_1
XFILLER_34_105 VGND VGND VPWR VPWR sky130_fd_sc_hd__decap_3
XFILLER_35_617 VGND VGND VPWR VPWR sky130_fd_sc_hd__decap_3
XFILLER_47_488 VGND VGND VPWR VPWR sky130_fd_sc_hd__decap_3
XFILLER_62_403 VGND VGND VPWR VPWR sky130_fd_sc_hd__decap_3
XFILLER_74_263 VGND VGND VPWR VPWR sky130_fd_sc_hd__decap_3
XFILLER_34_138 VGND VGND VPWR VPWR sky130_fd_sc_hd__fill_2
XFILLER_34_149 VGND VGND VPWR VPWR sky130_fd_sc_hd__decap_3
XFILLER_62_436 VGND VGND VPWR VPWR sky130_fd_sc_hd__decap_3
XFILLER_74_296 VGND VGND VPWR VPWR sky130_fd_sc_hd__decap_3
XFILLER_15_352 VGND VGND VPWR VPWR sky130_fd_sc_hd__decap_3
XFILLER_62_469 VGND VGND VPWR VPWR sky130_fd_sc_hd__decap_3
XTAP_TAPCELL_ROW_83_1253 VGND VPWR sky130_fd_sc_hd__tapvpwrvgnd_1
XTAP_TAPCELL_ROW_83_1242 VGND VPWR sky130_fd_sc_hd__tapvpwrvgnd_1
XFILLER_70_480 VGND VGND VPWR VPWR sky130_fd_sc_hd__decap_3
XFILLER_30_344 VGND VGND VPWR VPWR sky130_fd_sc_hd__decap_3
XFILLER_89_6 VGND VGND VPWR VPWR sky130_fd_sc_hd__decap_3
XFILLER_30_377 VGND VGND VPWR VPWR sky130_fd_sc_hd__decap_3
X_3500_ _4460_/A _4460_/B _3541_/B VGND VGND VPWR VPWR _3500_/Y sky130_fd_sc_hd__a21oi_2
XFILLER_116_405 VGND VGND VPWR VPWR sky130_fd_sc_hd__fill_1
XFILLER_116_427 VGND VGND VPWR VPWR sky130_fd_sc_hd__decap_3
X_4480_ _4480_/A0 _7307_/Q _4488_/S VGND VGND VPWR VPWR _7339_/D sky130_fd_sc_hd__mux2_2
XFILLER_116_449 VGND VGND VPWR VPWR sky130_fd_sc_hd__decap_3
X_3362_ _3362_/A _3561_/B _3386_/A VGND VGND VPWR VPWR _3362_/X sky130_fd_sc_hd__or3b_2
XTAP_TAPCELL_ROW_94_1382 VGND VPWR sky130_fd_sc_hd__tapvpwrvgnd_1
XFILLER_112_633 VGND VGND VPWR VPWR sky130_fd_sc_hd__decap_3
XFILLER_97_333 VGND VGND VPWR VPWR sky130_fd_sc_hd__decap_3
X_5101_ _5101_/A _5101_/B VGND VGND VPWR VPWR _5101_/Y sky130_fd_sc_hd__nor2_2
Xhold1207 _7165_/Q VGND VGND VPWR VPWR _5331_/A0 sky130_fd_sc_hd__dlygate4sd3_1
XFILLER_57_219 VGND VGND VPWR VPWR sky130_fd_sc_hd__decap_3
XFILLER_97_388 VGND VGND VPWR VPWR sky130_fd_sc_hd__decap_3
XFILLER_97_399 VGND VGND VPWR VPWR sky130_fd_sc_hd__decap_3
X_5032_ _5032_/A _5032_/B VGND VGND VPWR VPWR _5032_/Y sky130_fd_sc_hd__xnor2_2
XFILLER_38_488 VGND VGND VPWR VPWR sky130_fd_sc_hd__fill_1
XFILLER_65_263 VGND VGND VPWR VPWR sky130_fd_sc_hd__decap_3
XFILLER_93_561 VGND VGND VPWR VPWR sky130_fd_sc_hd__decap_3
XFILLER_19_691 VGND VGND VPWR VPWR sky130_fd_sc_hd__fill_1
XFILLER_25_116 VGND VGND VPWR VPWR sky130_fd_sc_hd__decap_3
XFILLER_53_447 VGND VGND VPWR VPWR sky130_fd_sc_hd__fill_1
XFILLER_80_222 VGND VGND VPWR VPWR sky130_fd_sc_hd__decap_3
XFILLER_93_594 VGND VGND VPWR VPWR sky130_fd_sc_hd__decap_3
X_6983_ _7364_/CLK _6983_/D _6263_/Y VGND VGND VPWR VPWR _6983_/Q sky130_fd_sc_hd__dfrtp_2
XTAP_TAPCELL_ROW_0_248 VGND VPWR sky130_fd_sc_hd__tapvpwrvgnd_1
XTAP_TAPCELL_ROW_0_237 VGND VPWR sky130_fd_sc_hd__tapvpwrvgnd_1
XFILLER_18_190 VGND VGND VPWR VPWR sky130_fd_sc_hd__decap_3
XTAP_TAPCELL_ROW_36_678 VGND VPWR sky130_fd_sc_hd__tapvpwrvgnd_1
XFILLER_80_277 VGND VGND VPWR VPWR sky130_fd_sc_hd__decap_3
XTAP_TAPCELL_ROW_36_689 VGND VPWR sky130_fd_sc_hd__tapvpwrvgnd_1
XFILLER_21_322 VGND VGND VPWR VPWR sky130_fd_sc_hd__decap_3
XFILLER_33_193 VGND VGND VPWR VPWR sky130_fd_sc_hd__decap_3
XFILLER_61_491 VGND VGND VPWR VPWR sky130_fd_sc_hd__fill_1
X_4816_ _4891_/A1 _4652_/A _4813_/A _5033_/B2 VGND VGND VPWR VPWR _4816_/X sky130_fd_sc_hd__a22o_2
X_4747_ _4739_/Y _4740_/X _4743_/X _4746_/X VGND VGND VPWR VPWR _5664_/B sky130_fd_sc_hd__o211a_2
XFILLER_107_416 VGND VGND VPWR VPWR sky130_fd_sc_hd__decap_3
XFILLER_110_9 VGND VGND VPWR VPWR sky130_fd_sc_hd__decap_3
X_4678_ _6988_/Q _4674_/X _5045_/B _5036_/A VGND VGND VPWR VPWR _5014_/B sky130_fd_sc_hd__a31o_2
XFILLER_107_449 VGND VGND VPWR VPWR sky130_fd_sc_hd__decap_3
X_7397_ _7401_/CLK _7397_/D _6677_/Y VGND VGND VPWR VPWR _7397_/Q sky130_fd_sc_hd__dfrtp_2
X_6417_ _6578_/A VGND VGND VPWR VPWR _6417_/Y sky130_fd_sc_hd__inv_2
X_3629_ _3629_/A VGND VGND VPWR VPWR _3629_/Y sky130_fd_sc_hd__inv_2
X_6348_ _6540_/A VGND VGND VPWR VPWR _6348_/Y sky130_fd_sc_hd__inv_2
XFILLER_88_333 VGND VGND VPWR VPWR sky130_fd_sc_hd__decap_3
XTAP_TAPCELL_ROW_8_348 VGND VPWR sky130_fd_sc_hd__tapvpwrvgnd_1
XFILLER_0_259 VGND VGND VPWR VPWR sky130_fd_sc_hd__decap_3
XFILLER_102_121 VGND VGND VPWR VPWR sky130_fd_sc_hd__decap_3
XFILLER_103_655 VGND VGND VPWR VPWR sky130_fd_sc_hd__decap_3
XFILLER_88_344 VGND VGND VPWR VPWR sky130_fd_sc_hd__decap_3
XFILLER_88_377 VGND VGND VPWR VPWR sky130_fd_sc_hd__decap_3
X_6279_ _6462_/A VGND VGND VPWR VPWR _6279_/Y sky130_fd_sc_hd__inv_2
XFILLER_29_411 VGND VGND VPWR VPWR sky130_fd_sc_hd__fill_1
XFILLER_76_528 VGND VGND VPWR VPWR sky130_fd_sc_hd__decap_3
XFILLER_76_539 VGND VGND VPWR VPWR sky130_fd_sc_hd__decap_3
XFILLER_88_399 VGND VGND VPWR VPWR sky130_fd_sc_hd__decap_3
XFILLER_56_230 VGND VGND VPWR VPWR sky130_fd_sc_hd__decap_3
XFILLER_16_105 VGND VGND VPWR VPWR sky130_fd_sc_hd__decap_3
XFILLER_17_617 VGND VGND VPWR VPWR sky130_fd_sc_hd__decap_3
XFILLER_44_403 VGND VGND VPWR VPWR sky130_fd_sc_hd__fill_2
XFILLER_56_274 VGND VGND VPWR VPWR sky130_fd_sc_hd__decap_3
XFILLER_56_68 VGND VGND VPWR VPWR sky130_fd_sc_hd__decap_3
XTAP_TAPCELL_ROW_55_910 VGND VPWR sky130_fd_sc_hd__tapvpwrvgnd_1
XTAP_TAPCELL_ROW_106_1518 VGND VPWR sky130_fd_sc_hd__tapvpwrvgnd_1
XFILLER_44_436 VGND VGND VPWR VPWR sky130_fd_sc_hd__decap_3
XFILLER_44_447 VGND VGND VPWR VPWR sky130_fd_sc_hd__decap_3
XFILLER_71_211 VGND VGND VPWR VPWR sky130_fd_sc_hd__decap_3
XTAP_TAPCELL_ROW_106_1529 VGND VPWR sky130_fd_sc_hd__tapvpwrvgnd_1
XFILLER_112_74 VGND VGND VPWR VPWR sky130_fd_sc_hd__decap_3
XFILLER_25_661 VGND VGND VPWR VPWR sky130_fd_sc_hd__decap_3
XFILLER_71_255 VGND VGND VPWR VPWR sky130_fd_sc_hd__decap_3
XFILLER_72_12 VGND VGND VPWR VPWR sky130_fd_sc_hd__decap_3
XFILLER_24_171 VGND VGND VPWR VPWR sky130_fd_sc_hd__decap_3
XFILLER_31_119 VGND VGND VPWR VPWR sky130_fd_sc_hd__decap_3
XFILLER_71_299 VGND VGND VPWR VPWR sky130_fd_sc_hd__decap_3
XFILLER_72_56 VGND VGND VPWR VPWR sky130_fd_sc_hd__decap_3
XFILLER_12_333 VGND VGND VPWR VPWR sky130_fd_sc_hd__decap_3
XFILLER_40_642 VGND VGND VPWR VPWR sky130_fd_sc_hd__fill_2
XFILLER_12_377 VGND VGND VPWR VPWR sky130_fd_sc_hd__decap_3
XFILLER_8_304 VGND VGND VPWR VPWR sky130_fd_sc_hd__decap_3
XFILLER_21_60 VGND VGND VPWR VPWR sky130_fd_sc_hd__decap_3
XFILLER_99_609 VGND VGND VPWR VPWR sky130_fd_sc_hd__decap_3
XFILLER_113_408 VGND VGND VPWR VPWR sky130_fd_sc_hd__decap_3
XFILLER_106_471 VGND VGND VPWR VPWR sky130_fd_sc_hd__decap_3
XFILLER_97_42 VGND VGND VPWR VPWR sky130_fd_sc_hd__decap_3
XFILLER_97_86 VGND VGND VPWR VPWR sky130_fd_sc_hd__fill_1
XFILLER_67_517 VGND VGND VPWR VPWR sky130_fd_sc_hd__decap_3
XFILLER_79_399 VGND VGND VPWR VPWR sky130_fd_sc_hd__decap_3
XFILLER_94_336 VGND VGND VPWR VPWR sky130_fd_sc_hd__decap_3
XFILLER_94_358 VGND VGND VPWR VPWR sky130_fd_sc_hd__decap_3
XFILLER_47_252 VGND VGND VPWR VPWR sky130_fd_sc_hd__decap_3
XFILLER_75_561 VGND VGND VPWR VPWR sky130_fd_sc_hd__decap_3
XFILLER_35_447 VGND VGND VPWR VPWR sky130_fd_sc_hd__fill_1
XFILLER_62_222 VGND VGND VPWR VPWR sky130_fd_sc_hd__decap_3
XFILLER_75_594 VGND VGND VPWR VPWR sky130_fd_sc_hd__decap_3
XFILLER_90_520 VGND VGND VPWR VPWR sky130_fd_sc_hd__decap_3
XFILLER_90_542 VGND VGND VPWR VPWR sky130_fd_sc_hd__fill_2
XFILLER_16_672 VGND VGND VPWR VPWR sky130_fd_sc_hd__fill_1
XFILLER_15_193 VGND VGND VPWR VPWR sky130_fd_sc_hd__decap_3
Xclkbuf_0_clk clk VGND VGND VPWR VPWR clkbuf_0_clk/X sky130_fd_sc_hd__clkbuf_16
X_5650_ _5650_/A VGND VGND VPWR VPWR _5650_/Y sky130_fd_sc_hd__inv_2
XTAP_TAPCELL_ROW_61_979 VGND VPWR sky130_fd_sc_hd__tapvpwrvgnd_1
XTAP_TAPCELL_ROW_33_648 VGND VPWR sky130_fd_sc_hd__tapvpwrvgnd_1
XFILLER_30_141 VGND VGND VPWR VPWR sky130_fd_sc_hd__decap_3
XFILLER_87_3 VGND VGND VPWR VPWR sky130_fd_sc_hd__decap_3
X_4601_ _7280_/Q _7248_/Q _4601_/S VGND VGND VPWR VPWR _7280_/D sky130_fd_sc_hd__mux2_2
XFILLER_30_174 VGND VGND VPWR VPWR sky130_fd_sc_hd__decap_3
X_5581_ _5581_/A0 _5069_/X _5595_/B VGND VGND VPWR VPWR _7038_/D sky130_fd_sc_hd__mux2_2
XTAP_TAPCELL_ROW_96_1400 VGND VPWR sky130_fd_sc_hd__tapvpwrvgnd_1
XFILLER_7_51 VGND VGND VPWR VPWR sky130_fd_sc_hd__decap_3
X_7320_ clkload8/A _7320_/D _6600_/Y VGND VGND VPWR VPWR _7320_/Q sky130_fd_sc_hd__dfrtp_2
X_4532_ _4532_/A0 _7281_/Q _4532_/S VGND VGND VPWR VPWR _7313_/D sky130_fd_sc_hd__mux2_2
XFILLER_7_370 VGND VGND VPWR VPWR sky130_fd_sc_hd__decap_3
X_7251_ clkload4/A _7251_/D _6531_/Y VGND VGND VPWR VPWR _7251_/Q sky130_fd_sc_hd__dfrtp_2
X_4463_ _4460_/Y _3541_/B _5057_/A _4462_/Y VGND VGND VPWR VPWR _4463_/X sky130_fd_sc_hd__a22o_2
XFILLER_116_268 VGND VGND VPWR VPWR sky130_fd_sc_hd__decap_3
XFILLER_89_108 VGND VGND VPWR VPWR sky130_fd_sc_hd__decap_3
XFILLER_89_119 VGND VGND VPWR VPWR sky130_fd_sc_hd__decap_3
X_3414_ _3421_/C VGND VGND VPWR VPWR _3449_/C sky130_fd_sc_hd__inv_4
X_7182_ _7340_/CLK _7182_/D _6462_/Y VGND VGND VPWR VPWR _7182_/Q sky130_fd_sc_hd__dfrtp_2
X_4394_ _4394_/A _4394_/B _4393_/X VGND VGND VPWR VPWR _4444_/B sky130_fd_sc_hd__or3b_2
XPHY_EDGE_ROW_15_Right_15 VGND VGND VPWR VPWR sky130_fd_sc_hd__decap_3
XFILLER_98_642 VGND VGND VPWR VPWR sky130_fd_sc_hd__fill_2
XFILLER_98_620 VGND VGND VPWR VPWR sky130_fd_sc_hd__decap_3
XFILLER_112_430 VGND VGND VPWR VPWR sky130_fd_sc_hd__decap_3
XFILLER_58_506 VGND VGND VPWR VPWR sky130_fd_sc_hd__fill_2
X_3345_ _5642_/A _4677_/B VGND VGND VPWR VPWR _3346_/A sky130_fd_sc_hd__nor2_4
XTAP_TAPCELL_ROW_5_307 VGND VPWR sky130_fd_sc_hd__tapvpwrvgnd_1
XFILLER_100_625 VGND VGND VPWR VPWR sky130_fd_sc_hd__decap_3
XFILLER_58_528 VGND VGND VPWR VPWR sky130_fd_sc_hd__decap_3
XFILLER_58_539 VGND VGND VPWR VPWR sky130_fd_sc_hd__decap_3
XFILLER_85_325 VGND VGND VPWR VPWR sky130_fd_sc_hd__decap_3
XFILLER_97_163 VGND VGND VPWR VPWR sky130_fd_sc_hd__decap_3
Xhold1004 _7191_/Q VGND VGND VPWR VPWR _5278_/A0 sky130_fd_sc_hd__dlygate4sd3_1
Xhold1015 _7405_/Q VGND VGND VPWR VPWR _3671_/A1 sky130_fd_sc_hd__dlygate4sd3_1
Xhold1026 _7212_/Q VGND VGND VPWR VPWR _5236_/A0 sky130_fd_sc_hd__dlygate4sd3_1
Xhold1037 _7313_/Q VGND VGND VPWR VPWR _4532_/A0 sky130_fd_sc_hd__dlygate4sd3_1
Xhold1048 _7262_/Q VGND VGND VPWR VPWR _4998_/A0 sky130_fd_sc_hd__dlygate4sd3_1
X_5015_ _5577_/S _5015_/B _5015_/C VGND VGND VPWR VPWR _5015_/X sky130_fd_sc_hd__and3_2
Xhold1059 _7288_/Q VGND VGND VPWR VPWR _4585_/A sky130_fd_sc_hd__dlygate4sd3_1
XFILLER_26_27 VGND VGND VPWR VPWR sky130_fd_sc_hd__fill_1
XFILLER_26_38 VGND VGND VPWR VPWR sky130_fd_sc_hd__fill_1
XFILLER_26_436 VGND VGND VPWR VPWR sky130_fd_sc_hd__fill_2
XFILLER_38_274 VGND VGND VPWR VPWR sky130_fd_sc_hd__decap_3
XFILLER_38_296 VGND VGND VPWR VPWR sky130_fd_sc_hd__decap_3
XFILLER_93_391 VGND VGND VPWR VPWR sky130_fd_sc_hd__fill_1
XFILLER_26_49 VGND VGND VPWR VPWR sky130_fd_sc_hd__decap_3
XFILLER_81_553 VGND VGND VPWR VPWR sky130_fd_sc_hd__decap_3
XFILLER_81_564 VGND VGND VPWR VPWR sky130_fd_sc_hd__decap_3
X_6966_ _6966_/CLK _6966_/D VGND VGND VPWR VPWR _6966_/Q sky130_fd_sc_hd__dfxtp_2
XPHY_EDGE_ROW_24_Right_24 VGND VGND VPWR VPWR sky130_fd_sc_hd__decap_3
XFILLER_13_119 VGND VGND VPWR VPWR sky130_fd_sc_hd__decap_3
XFILLER_41_428 VGND VGND VPWR VPWR sky130_fd_sc_hd__decap_3
XFILLER_53_299 VGND VGND VPWR VPWR sky130_fd_sc_hd__decap_3
XFILLER_81_597 VGND VGND VPWR VPWR sky130_fd_sc_hd__decap_3
XFILLER_21_130 VGND VGND VPWR VPWR sky130_fd_sc_hd__decap_3
XFILLER_34_480 VGND VGND VPWR VPWR sky130_fd_sc_hd__fill_1
XFILLER_34_491 VGND VGND VPWR VPWR sky130_fd_sc_hd__fill_1
XFILLER_42_15 VGND VGND VPWR VPWR sky130_fd_sc_hd__decap_3
X_6897_ _6936_/CLK _6897_/D VGND VGND VPWR VPWR _6897_/Q sky130_fd_sc_hd__dfxtp_2
XFILLER_21_163 VGND VGND VPWR VPWR sky130_fd_sc_hd__fill_1
XFILLER_22_664 VGND VGND VPWR VPWR sky130_fd_sc_hd__fill_2
XTAP_TAPCELL_ROW_101_1459 VGND VPWR sky130_fd_sc_hd__tapvpwrvgnd_1
XFILLER_21_196 VGND VGND VPWR VPWR sky130_fd_sc_hd__decap_3
XFILLER_107_202 VGND VGND VPWR VPWR sky130_fd_sc_hd__decap_3
XFILLER_5_329 VGND VGND VPWR VPWR sky130_fd_sc_hd__decap_3
XFILLER_107_246 VGND VGND VPWR VPWR sky130_fd_sc_hd__decap_3
XFILLER_1_502 VGND VGND VPWR VPWR sky130_fd_sc_hd__fill_2
XPHY_EDGE_ROW_33_Right_33 VGND VGND VPWR VPWR sky130_fd_sc_hd__decap_3
XFILLER_107_41 VGND VGND VPWR VPWR sky130_fd_sc_hd__decap_3
XFILLER_89_620 VGND VGND VPWR VPWR sky130_fd_sc_hd__decap_3
Xhold860 _7085_/Q VGND VGND VPWR VPWR _7085_/D sky130_fd_sc_hd__dlygate4sd3_1
Xhold871 _7102_/Q VGND VGND VPWR VPWR _7102_/D sky130_fd_sc_hd__dlygate4sd3_1
Xhold882 _7106_/Q VGND VGND VPWR VPWR _7106_/D sky130_fd_sc_hd__dlygate4sd3_1
XFILLER_103_452 VGND VGND VPWR VPWR sky130_fd_sc_hd__decap_3
XFILLER_107_63 VGND VGND VPWR VPWR sky130_fd_sc_hd__decap_3
XFILLER_88_141 VGND VGND VPWR VPWR sky130_fd_sc_hd__decap_3
XFILLER_89_653 VGND VGND VPWR VPWR sky130_fd_sc_hd__decap_3
Xhold893 _7072_/Q VGND VGND VPWR VPWR _7072_/D sky130_fd_sc_hd__dlygate4sd3_1
XFILLER_107_96 VGND VGND VPWR VPWR sky130_fd_sc_hd__decap_3
XFILLER_88_174 VGND VGND VPWR VPWR sky130_fd_sc_hd__decap_3
XTAP_TAPCELL_ROW_112_1599 VGND VPWR sky130_fd_sc_hd__tapvpwrvgnd_1
XFILLER_103_496 VGND VGND VPWR VPWR sky130_fd_sc_hd__decap_3
XFILLER_67_67 VGND VGND VPWR VPWR sky130_fd_sc_hd__decap_3
XFILLER_76_336 VGND VGND VPWR VPWR sky130_fd_sc_hd__decap_3
XFILLER_29_263 VGND VGND VPWR VPWR sky130_fd_sc_hd__fill_1
XFILLER_57_561 VGND VGND VPWR VPWR sky130_fd_sc_hd__decap_3
XFILLER_91_306 VGND VGND VPWR VPWR sky130_fd_sc_hd__decap_3
XFILLER_44_200 VGND VGND VPWR VPWR sky130_fd_sc_hd__decap_3
XFILLER_72_520 VGND VGND VPWR VPWR sky130_fd_sc_hd__decap_3
XFILLER_84_380 VGND VGND VPWR VPWR sky130_fd_sc_hd__decap_3
XPHY_EDGE_ROW_42_Right_42 VGND VGND VPWR VPWR sky130_fd_sc_hd__decap_3
XFILLER_17_458 VGND VGND VPWR VPWR sky130_fd_sc_hd__fill_1
XFILLER_83_77 VGND VGND VPWR VPWR sky130_fd_sc_hd__decap_3
XTAP_TAPCELL_ROW_67_1056 VGND VPWR sky130_fd_sc_hd__tapvpwrvgnd_1
XFILLER_13_653 VGND VGND VPWR VPWR sky130_fd_sc_hd__fill_2
XTAP_TAPCELL_ROW_80_1212 VGND VPWR sky130_fd_sc_hd__tapvpwrvgnd_1
XFILLER_12_141 VGND VGND VPWR VPWR sky130_fd_sc_hd__decap_3
XFILLER_8_112 VGND VGND VPWR VPWR sky130_fd_sc_hd__decap_3
XTAP_TAPCELL_ROW_30_607 VGND VPWR sky130_fd_sc_hd__tapvpwrvgnd_1
XFILLER_40_483 VGND VGND VPWR VPWR sky130_fd_sc_hd__decap_3
XFILLER_9_646 VGND VGND VPWR VPWR sky130_fd_sc_hd__fill_1
XFILLER_8_156 VGND VGND VPWR VPWR sky130_fd_sc_hd__decap_3
XPHY_EDGE_ROW_51_Right_51 VGND VGND VPWR VPWR sky130_fd_sc_hd__decap_3
XFILLER_8_189 VGND VGND VPWR VPWR sky130_fd_sc_hd__decap_3
XTAP_TAPCELL_ROW_10_375 VGND VPWR sky130_fd_sc_hd__tapvpwrvgnd_1
XFILLER_4_351 VGND VGND VPWR VPWR sky130_fd_sc_hd__decap_3
XTAP_TAPCELL_ROW_78_1185 VGND VPWR sky130_fd_sc_hd__tapvpwrvgnd_1
XFILLER_99_417 VGND VGND VPWR VPWR sky130_fd_sc_hd__decap_3
XFILLER_113_216 VGND VGND VPWR VPWR sky130_fd_sc_hd__decap_3
XTAP_TAPCELL_ROW_91_1341 VGND VPWR sky130_fd_sc_hd__tapvpwrvgnd_1
XFILLER_67_325 VGND VGND VPWR VPWR sky130_fd_sc_hd__decap_3
XFILLER_79_152 VGND VGND VPWR VPWR sky130_fd_sc_hd__fill_2
XFILLER_95_623 VGND VGND VPWR VPWR sky130_fd_sc_hd__decap_3
XFILLER_67_358 VGND VGND VPWR VPWR sky130_fd_sc_hd__decap_3
XFILLER_94_122 VGND VGND VPWR VPWR sky130_fd_sc_hd__decap_3
XFILLER_94_155 VGND VGND VPWR VPWR sky130_fd_sc_hd__decap_3
XTAP_TAPCELL_ROW_38_707 VGND VPWR sky130_fd_sc_hd__tapvpwrvgnd_1
XPHY_EDGE_ROW_60_Right_60 VGND VGND VPWR VPWR sky130_fd_sc_hd__decap_3
XFILLER_35_222 VGND VGND VPWR VPWR sky130_fd_sc_hd__fill_2
XFILLER_63_531 VGND VGND VPWR VPWR sky130_fd_sc_hd__decap_3
XFILLER_75_380 VGND VGND VPWR VPWR sky130_fd_sc_hd__decap_3
XFILLER_35_233 VGND VGND VPWR VPWR sky130_fd_sc_hd__decap_3
XFILLER_63_564 VGND VGND VPWR VPWR sky130_fd_sc_hd__decap_3
X_6820_ _6967_/CLK _6820_/D VGND VGND VPWR VPWR _6820_/Q sky130_fd_sc_hd__dfxtp_2
XFILLER_23_417 VGND VGND VPWR VPWR sky130_fd_sc_hd__fill_2
XFILLER_50_203 VGND VGND VPWR VPWR sky130_fd_sc_hd__decap_3
XFILLER_90_383 VGND VGND VPWR VPWR sky130_fd_sc_hd__decap_3
XTAP_TAPCELL_ROW_18_464 VGND VPWR sky130_fd_sc_hd__tapvpwrvgnd_1
XFILLER_50_247 VGND VGND VPWR VPWR sky130_fd_sc_hd__decap_3
X_6751_ _6967_/CLK _6751_/D VGND VGND VPWR VPWR _6751_/Q sky130_fd_sc_hd__dfxtp_2
X_6682_ _6682_/A VGND VGND VPWR VPWR _6682_/Y sky130_fd_sc_hd__inv_2
X_3894_ _3728_/Y _3891_/X _3893_/X _3733_/X VGND VGND VPWR VPWR _3894_/X sky130_fd_sc_hd__a22o_2
XFILLER_12_18 VGND VGND VPWR VPWR sky130_fd_sc_hd__decap_3
XFILLER_31_472 VGND VGND VPWR VPWR sky130_fd_sc_hd__decap_3
XFILLER_31_494 VGND VGND VPWR VPWR sky130_fd_sc_hd__fill_1
X_5633_ _5633_/A _5633_/B VGND VGND VPWR VPWR _7012_/D sky130_fd_sc_hd__nor2_2
XFILLER_12_29 VGND VGND VPWR VPWR sky130_fd_sc_hd__decap_3
X_5564_ hold981/X _5647_/A _4751_/B VGND VGND VPWR VPWR _7052_/D sky130_fd_sc_hd__a21bo_2
X_7303_ _7371_/CLK _7303_/D _6583_/Y VGND VGND VPWR VPWR _7303_/Q sky130_fd_sc_hd__dfrtp_2
X_4515_ _7322_/Q _7290_/Q _4532_/S VGND VGND VPWR VPWR _7322_/D sky130_fd_sc_hd__mux2_2
XPHY_EDGE_ROW_103_Right_103 VGND VGND VPWR VPWR sky130_fd_sc_hd__decap_3
X_7234_ _7363_/CLK _7234_/D _6514_/Y VGND VGND VPWR VPWR _7234_/Q sky130_fd_sc_hd__dfrtp_2
X_4446_ _4446_/A _4814_/B VGND VGND VPWR VPWR _4447_/B sky130_fd_sc_hd__nor2_2
XFILLER_104_249 VGND VGND VPWR VPWR sky130_fd_sc_hd__decap_3
X_7165_ _7360_/CLK _7165_/D _6445_/Y VGND VGND VPWR VPWR _7165_/Q sky130_fd_sc_hd__dfrtp_2
X_4377_ _4620_/C _4375_/X _4376_/X VGND VGND VPWR VPWR _4377_/Y sky130_fd_sc_hd__o21ai_2
XFILLER_98_450 VGND VGND VPWR VPWR sky130_fd_sc_hd__decap_3
XFILLER_58_303 VGND VGND VPWR VPWR sky130_fd_sc_hd__decap_3
X_3328_ _3328_/A _3328_/B VGND VGND VPWR VPWR _3340_/C sky130_fd_sc_hd__nor2_2
XPHY_EDGE_ROW_13_Left_130 VGND VGND VPWR VPWR sky130_fd_sc_hd__decap_3
XFILLER_98_483 VGND VGND VPWR VPWR sky130_fd_sc_hd__decap_3
XFILLER_112_271 VGND VGND VPWR VPWR sky130_fd_sc_hd__decap_3
XFILLER_37_15 VGND VGND VPWR VPWR sky130_fd_sc_hd__decap_3
XFILLER_58_347 VGND VGND VPWR VPWR sky130_fd_sc_hd__decap_3
XFILLER_85_111 VGND VGND VPWR VPWR sky130_fd_sc_hd__fill_1
XFILLER_85_133 VGND VGND VPWR VPWR sky130_fd_sc_hd__decap_3
XFILLER_86_645 VGND VGND VPWR VPWR sky130_fd_sc_hd__decap_3
X_7096_ clkload4/A _7096_/D _6376_/Y VGND VGND VPWR VPWR _7096_/Q sky130_fd_sc_hd__dfrtp_2
XFILLER_100_477 VGND VGND VPWR VPWR sky130_fd_sc_hd__decap_3
XFILLER_46_509 VGND VGND VPWR VPWR sky130_fd_sc_hd__fill_1
XFILLER_85_166 VGND VGND VPWR VPWR sky130_fd_sc_hd__fill_2
XFILLER_26_200 VGND VGND VPWR VPWR sky130_fd_sc_hd__decap_3
XFILLER_73_328 VGND VGND VPWR VPWR sky130_fd_sc_hd__decap_3
XFILLER_85_188 VGND VGND VPWR VPWR sky130_fd_sc_hd__decap_3
XFILLER_14_417 VGND VGND VPWR VPWR sky130_fd_sc_hd__decap_3
XFILLER_26_266 VGND VGND VPWR VPWR sky130_fd_sc_hd__decap_3
XFILLER_54_586 VGND VGND VPWR VPWR sky130_fd_sc_hd__fill_2
XFILLER_81_361 VGND VGND VPWR VPWR sky130_fd_sc_hd__decap_3
XFILLER_41_225 VGND VGND VPWR VPWR sky130_fd_sc_hd__fill_1
XFILLER_41_247 VGND VGND VPWR VPWR sky130_fd_sc_hd__decap_3
XFILLER_53_69 VGND VGND VPWR VPWR sky130_fd_sc_hd__decap_3
X_6949_ _6967_/CLK _6949_/D VGND VGND VPWR VPWR _6949_/Q sky130_fd_sc_hd__dfxtp_2
XFILLER_108_533 VGND VGND VPWR VPWR sky130_fd_sc_hd__decap_3
XFILLER_5_137 VGND VGND VPWR VPWR sky130_fd_sc_hd__decap_3
XFILLER_108_566 VGND VGND VPWR VPWR sky130_fd_sc_hd__decap_3
XTAP_TAPCELL_ROW_114_1617 VGND VPWR sky130_fd_sc_hd__tapvpwrvgnd_1
XFILLER_1_343 VGND VGND VPWR VPWR sky130_fd_sc_hd__decap_3
XFILLER_78_66 VGND VGND VPWR VPWR sky130_fd_sc_hd__decap_3
XFILLER_96_409 VGND VGND VPWR VPWR sky130_fd_sc_hd__decap_3
Xhold690 _6881_/Q VGND VGND VPWR VPWR _6881_/D sky130_fd_sc_hd__dlygate4sd3_1
XFILLER_110_208 VGND VGND VPWR VPWR sky130_fd_sc_hd__fill_2
XFILLER_49_303 VGND VGND VPWR VPWR sky130_fd_sc_hd__decap_3
XFILLER_77_601 VGND VGND VPWR VPWR sky130_fd_sc_hd__decap_3
XFILLER_78_88 VGND VGND VPWR VPWR sky130_fd_sc_hd__decap_3
XFILLER_89_461 VGND VGND VPWR VPWR sky130_fd_sc_hd__decap_3
XFILLER_103_293 VGND VGND VPWR VPWR sky130_fd_sc_hd__decap_3
XFILLER_76_133 VGND VGND VPWR VPWR sky130_fd_sc_hd__decap_3
XFILLER_89_494 VGND VGND VPWR VPWR sky130_fd_sc_hd__decap_3
XFILLER_49_358 VGND VGND VPWR VPWR sky130_fd_sc_hd__decap_3
XFILLER_76_144 VGND VGND VPWR VPWR sky130_fd_sc_hd__fill_1
XFILLER_94_32 VGND VGND VPWR VPWR sky130_fd_sc_hd__decap_3
XFILLER_17_211 VGND VGND VPWR VPWR sky130_fd_sc_hd__decap_3
XFILLER_92_648 VGND VGND VPWR VPWR sky130_fd_sc_hd__fill_2
XFILLER_94_65 VGND VGND VPWR VPWR sky130_fd_sc_hd__decap_3
XFILLER_27_81 VGND VGND VPWR VPWR sky130_fd_sc_hd__decap_3
XFILLER_17_277 VGND VGND VPWR VPWR sky130_fd_sc_hd__decap_3
XFILLER_60_501 VGND VGND VPWR VPWR sky130_fd_sc_hd__decap_3
XFILLER_60_523 VGND VGND VPWR VPWR sky130_fd_sc_hd__fill_1
XFILLER_32_225 VGND VGND VPWR VPWR sky130_fd_sc_hd__decap_3
XFILLER_32_247 VGND VGND VPWR VPWR sky130_fd_sc_hd__decap_3
XFILLER_60_545 VGND VGND VPWR VPWR sky130_fd_sc_hd__decap_3
XTAP_TAPCELL_ROW_15_434 VGND VPWR sky130_fd_sc_hd__tapvpwrvgnd_1
XTAP_TAPCELL_ROW_43_765 VGND VPWR sky130_fd_sc_hd__tapvpwrvgnd_1
XFILLER_40_280 VGND VGND VPWR VPWR sky130_fd_sc_hd__decap_3
XFILLER_71_6 VGND VGND VPWR VPWR sky130_fd_sc_hd__fill_2
XFILLER_114_536 VGND VGND VPWR VPWR sky130_fd_sc_hd__decap_3
X_5280_ _5280_/A0 _5121_/X _5292_/S VGND VGND VPWR VPWR _7190_/D sky130_fd_sc_hd__mux2_2
X_4300_ _7288_/Q _4522_/S VGND VGND VPWR VPWR _4300_/X sky130_fd_sc_hd__and2_2
XFILLER_99_225 VGND VGND VPWR VPWR sky130_fd_sc_hd__decap_3
XFILLER_99_214 VGND VGND VPWR VPWR sky130_fd_sc_hd__decap_3
XFILLER_4_170 VGND VGND VPWR VPWR sky130_fd_sc_hd__decap_3
X_4231_ _7040_/Q _4510_/S _3380_/Y _7387_/Q _4230_/X VGND VGND VPWR VPWR _4231_/X
+ sky130_fd_sc_hd__a221o_2
XFILLER_99_258 VGND VGND VPWR VPWR sky130_fd_sc_hd__decap_3
XFILLER_101_219 VGND VGND VPWR VPWR sky130_fd_sc_hd__decap_3
XFILLER_4_63 VGND VGND VPWR VPWR sky130_fd_sc_hd__decap_3
XFILLER_4_85 VGND VGND VPWR VPWR sky130_fd_sc_hd__decap_3
XFILLER_68_601 VGND VGND VPWR VPWR sky130_fd_sc_hd__fill_2
XFILLER_67_111 VGND VGND VPWR VPWR sky130_fd_sc_hd__fill_1
XFILLER_67_122 VGND VGND VPWR VPWR sky130_fd_sc_hd__decap_3
XFILLER_68_645 VGND VGND VPWR VPWR sky130_fd_sc_hd__decap_3
X_4162_ _7137_/Q _4190_/B1 _4161_/X VGND VGND VPWR VPWR _4203_/A sky130_fd_sc_hd__a21o_2
XFILLER_67_144 VGND VGND VPWR VPWR sky130_fd_sc_hd__decap_3
XFILLER_95_464 VGND VGND VPWR VPWR sky130_fd_sc_hd__decap_3
X_4093_ _4394_/A _4394_/B _4092_/X VGND VGND VPWR VPWR _4210_/B sky130_fd_sc_hd__or3b_2
XFILLER_83_637 VGND VGND VPWR VPWR sky130_fd_sc_hd__decap_3
XFILLER_95_497 VGND VGND VPWR VPWR sky130_fd_sc_hd__decap_3
XFILLER_36_531 VGND VGND VPWR VPWR sky130_fd_sc_hd__fill_1
XFILLER_82_147 VGND VGND VPWR VPWR sky130_fd_sc_hd__decap_3
XFILLER_23_203 VGND VGND VPWR VPWR sky130_fd_sc_hd__decap_3
XFILLER_63_361 VGND VGND VPWR VPWR sky130_fd_sc_hd__decap_3
XFILLER_23_225 VGND VGND VPWR VPWR sky130_fd_sc_hd__decap_3
XFILLER_51_545 VGND VGND VPWR VPWR sky130_fd_sc_hd__fill_1
Xplace372 _3757_/S VGND VGND VPWR VPWR _4799_/A sky130_fd_sc_hd__buf_2
Xplace361 _5136_/S VGND VGND VPWR VPWR _5159_/S sky130_fd_sc_hd__buf_2
Xplace350 _3449_/X VGND VGND VPWR VPWR _4337_/B sky130_fd_sc_hd__buf_2
X_6803_ _7404_/CLK _6803_/D VGND VGND VPWR VPWR _6803_/Q sky130_fd_sc_hd__dfxtp_2
X_4995_ _5103_/A1 _4987_/Y _4993_/X _4994_/X VGND VGND VPWR VPWR _5657_/D sky130_fd_sc_hd__a211o_2
XFILLER_23_269 VGND VGND VPWR VPWR sky130_fd_sc_hd__decap_3
Xplace383 _3378_/Y VGND VGND VPWR VPWR _4190_/B1 sky130_fd_sc_hd__buf_2
Xplace394 _5642_/A VGND VGND VPWR VPWR _5666_/A sky130_fd_sc_hd__buf_2
X_6734_ _6968_/CLK _6734_/D VGND VGND VPWR VPWR _6734_/Q sky130_fd_sc_hd__dfxtp_2
XFILLER_109_319 VGND VGND VPWR VPWR sky130_fd_sc_hd__decap_3
X_6665_ _6670_/A VGND VGND VPWR VPWR _6665_/Y sky130_fd_sc_hd__inv_2
X_3877_ _6906_/Q _3890_/A2 _3889_/B1 _6850_/Q _3876_/X VGND VGND VPWR VPWR _3877_/X
+ sky130_fd_sc_hd__a221o_2
X_6596_ _6599_/A VGND VGND VPWR VPWR _6596_/Y sky130_fd_sc_hd__inv_2
XFILLER_3_9 VGND VGND VPWR VPWR sky130_fd_sc_hd__decap_3
X_7217_ clkload3/A _7217_/D _6497_/Y VGND VGND VPWR VPWR _7217_/Q sky130_fd_sc_hd__dfrtp_2
X_4429_ _7303_/Q _4488_/S _4437_/B1 _7367_/Q _4429_/C1 VGND VGND VPWR VPWR _4429_/X
+ sky130_fd_sc_hd__a221o_2
XFILLER_48_25 VGND VGND VPWR VPWR sky130_fd_sc_hd__decap_3
XFILLER_58_133 VGND VGND VPWR VPWR sky130_fd_sc_hd__decap_3
XFILLER_59_645 VGND VGND VPWR VPWR sky130_fd_sc_hd__decap_3
XFILLER_86_442 VGND VGND VPWR VPWR sky130_fd_sc_hd__decap_3
X_7148_ _7340_/CLK _7148_/D _6428_/Y VGND VGND VPWR VPWR _7148_/Q sky130_fd_sc_hd__dfrtp_2
XFILLER_98_280 VGND VGND VPWR VPWR sky130_fd_sc_hd__decap_3
XFILLER_58_144 VGND VGND VPWR VPWR sky130_fd_sc_hd__decap_3
XFILLER_74_604 VGND VGND VPWR VPWR sky130_fd_sc_hd__decap_3
X_7079_ _7330_/CLK _7079_/D _6359_/Y VGND VGND VPWR VPWR _7079_/Q sky130_fd_sc_hd__dfrtp_2
XFILLER_104_53 VGND VGND VPWR VPWR sky130_fd_sc_hd__decap_3
XFILLER_58_177 VGND VGND VPWR VPWR sky130_fd_sc_hd__decap_3
XFILLER_14_203 VGND VGND VPWR VPWR sky130_fd_sc_hd__decap_3
XFILLER_54_350 VGND VGND VPWR VPWR sky130_fd_sc_hd__decap_3
XFILLER_73_169 VGND VGND VPWR VPWR sky130_fd_sc_hd__decap_3
XTAP_TAPCELL_ROW_64_1015 VGND VPWR sky130_fd_sc_hd__tapvpwrvgnd_1
XFILLER_54_394 VGND VGND VPWR VPWR sky130_fd_sc_hd__decap_3
Xfanout40 _6547_/A VGND VGND VPWR VPWR _6548_/A sky130_fd_sc_hd__buf_2
XFILLER_80_56 VGND VGND VPWR VPWR sky130_fd_sc_hd__decap_3
Xfanout51 reset VGND VGND VPWR VPWR wire582/A sky130_fd_sc_hd__buf_1
Xfanout62 fanout72/X VGND VGND VPWR VPWR _6587_/A sky130_fd_sc_hd__clkdlybuf4s25_1
Xfanout73 reset VGND VGND VPWR VPWR _6462_/A sky130_fd_sc_hd__buf_1
XTAP_TAPCELL_ROW_40_735 VGND VPWR sky130_fd_sc_hd__tapvpwrvgnd_1
XFILLER_6_402 VGND VGND VPWR VPWR sky130_fd_sc_hd__decap_3
XFILLER_80_78 VGND VGND VPWR VPWR sky130_fd_sc_hd__decap_3
XFILLER_13_72 VGND VGND VPWR VPWR sky130_fd_sc_hd__decap_3
XFILLER_108_330 VGND VGND VPWR VPWR sky130_fd_sc_hd__decap_3
XFILLER_89_21 VGND VGND VPWR VPWR sky130_fd_sc_hd__decap_3
XFILLER_89_43 VGND VGND VPWR VPWR sky130_fd_sc_hd__decap_3
XTAP_TAPCELL_ROW_20_492 VGND VPWR sky130_fd_sc_hd__tapvpwrvgnd_1
XFILLER_108_363 VGND VGND VPWR VPWR sky130_fd_sc_hd__fill_1
XFILLER_108_374 VGND VGND VPWR VPWR sky130_fd_sc_hd__decap_3
XFILLER_2_641 VGND VGND VPWR VPWR sky130_fd_sc_hd__decap_3
XFILLER_89_87 VGND VGND VPWR VPWR sky130_fd_sc_hd__decap_3
XTAP_TAPCELL_ROW_75_1155 VGND VPWR sky130_fd_sc_hd__tapvpwrvgnd_1
XFILLER_1_140 VGND VGND VPWR VPWR sky130_fd_sc_hd__decap_3
XFILLER_36_9 VGND VGND VPWR VPWR sky130_fd_sc_hd__decap_3
XFILLER_96_206 VGND VGND VPWR VPWR sky130_fd_sc_hd__decap_3
XFILLER_1_184 VGND VGND VPWR VPWR sky130_fd_sc_hd__decap_3
XFILLER_49_100 VGND VGND VPWR VPWR sky130_fd_sc_hd__decap_3
XFILLER_49_111 VGND VGND VPWR VPWR sky130_fd_sc_hd__fill_1
XFILLER_49_122 VGND VGND VPWR VPWR sky130_fd_sc_hd__decap_3
XFILLER_77_420 VGND VGND VPWR VPWR sky130_fd_sc_hd__decap_3
XFILLER_49_155 VGND VGND VPWR VPWR sky130_fd_sc_hd__decap_3
XFILLER_77_475 VGND VGND VPWR VPWR sky130_fd_sc_hd__decap_3
XFILLER_37_317 VGND VGND VPWR VPWR sky130_fd_sc_hd__fill_2
XFILLER_37_328 VGND VGND VPWR VPWR sky130_fd_sc_hd__decap_3
XFILLER_64_114 VGND VGND VPWR VPWR sky130_fd_sc_hd__decap_3
XFILLER_65_637 VGND VGND VPWR VPWR sky130_fd_sc_hd__decap_3
XFILLER_92_401 VGND VGND VPWR VPWR sky130_fd_sc_hd__decap_3
XTAP_TAPCELL_ROW_48_824 VGND VPWR sky130_fd_sc_hd__tapvpwrvgnd_1
XFILLER_38_91 VGND VGND VPWR VPWR sky130_fd_sc_hd__decap_3
XFILLER_92_467 VGND VGND VPWR VPWR sky130_fd_sc_hd__decap_3
XFILLER_52_309 VGND VGND VPWR VPWR sky130_fd_sc_hd__decap_3
XFILLER_64_169 VGND VGND VPWR VPWR sky130_fd_sc_hd__decap_3
XFILLER_80_629 VGND VGND VPWR VPWR sky130_fd_sc_hd__decap_3
XFILLER_92_489 VGND VGND VPWR VPWR sky130_fd_sc_hd__decap_3
XFILLER_60_331 VGND VGND VPWR VPWR sky130_fd_sc_hd__decap_3
XFILLER_72_180 VGND VGND VPWR VPWR sky130_fd_sc_hd__fill_1
XTAP_TAPCELL_ROW_86_1284 VGND VPWR sky130_fd_sc_hd__tapvpwrvgnd_1
XTAP_TAPCELL_ROW_28_592 VGND VPWR sky130_fd_sc_hd__tapvpwrvgnd_1
X_4780_ _4779_/X _4447_/B _4795_/A VGND VGND VPWR VPWR _4780_/Y sky130_fd_sc_hd__a21oi_2
X_3800_ _6861_/Q _3882_/A2 _3881_/B1 _6901_/Q _3799_/X VGND VGND VPWR VPWR _3800_/X
+ sky130_fd_sc_hd__a221o_2
XFILLER_20_239 VGND VGND VPWR VPWR sky130_fd_sc_hd__decap_3
XFILLER_60_397 VGND VGND VPWR VPWR sky130_fd_sc_hd__decap_3
X_3731_ _6758_/Q _3826_/A2 _3912_/B1 _6770_/Q VGND VGND VPWR VPWR _3731_/X sky130_fd_sc_hd__a22o_2
XFILLER_9_240 VGND VGND VPWR VPWR sky130_fd_sc_hd__decap_3
Xclkload10 _6976_/CLK VGND VGND VPWR VPWR clkload10/X sky130_fd_sc_hd__clkbuf_1
X_6450_ _6611_/A VGND VGND VPWR VPWR _6450_/Y sky130_fd_sc_hd__inv_2
Xclkload21 _7364_/CLK VGND VGND VPWR VPWR clkload21/X sky130_fd_sc_hd__clkbuf_1
Xclkload32 _7401_/CLK VGND VGND VPWR VPWR clkload32/Y sky130_fd_sc_hd__inv_6
X_6381_ _6539_/A VGND VGND VPWR VPWR _6381_/Y sky130_fd_sc_hd__inv_2
X_3593_ _3620_/A _4292_/B _3592_/X VGND VGND VPWR VPWR _3594_/B sky130_fd_sc_hd__a21o_2
XFILLER_102_528 VGND VGND VPWR VPWR sky130_fd_sc_hd__decap_3
XFILLER_114_355 VGND VGND VPWR VPWR sky130_fd_sc_hd__decap_3
XFILLER_114_388 VGND VGND VPWR VPWR sky130_fd_sc_hd__decap_3
XFILLER_87_206 VGND VGND VPWR VPWR sky130_fd_sc_hd__decap_3
X_7002_ _7368_/CLK _7002_/D _6282_/Y VGND VGND VPWR VPWR _7002_/Q sky130_fd_sc_hd__dfrtp_2
X_5194_ _5194_/A _5194_/B VGND VGND VPWR VPWR _7231_/D sky130_fd_sc_hd__and2_2
X_4214_ _7228_/Q _4262_/A2 _4348_/A2 _7164_/Q _4213_/X VGND VGND VPWR VPWR _4214_/X
+ sky130_fd_sc_hd__a221o_2
XFILLER_18_17 VGND VGND VPWR VPWR sky130_fd_sc_hd__decap_3
XFILLER_68_442 VGND VGND VPWR VPWR sky130_fd_sc_hd__decap_3
X_4145_ _7298_/Q _4501_/S _4144_/X _4188_/C1 VGND VGND VPWR VPWR _4145_/X sky130_fd_sc_hd__a211o_2
XFILLER_28_339 VGND VGND VPWR VPWR sky130_fd_sc_hd__fill_2
XFILLER_68_497 VGND VGND VPWR VPWR sky130_fd_sc_hd__decap_3
XFILLER_95_261 VGND VGND VPWR VPWR sky130_fd_sc_hd__decap_3
X_4076_ _7147_/Q _4434_/B1 _4436_/B1 _7179_/Q VGND VGND VPWR VPWR _4076_/X sky130_fd_sc_hd__a22o_2
XFILLER_36_361 VGND VGND VPWR VPWR sky130_fd_sc_hd__decap_3
XFILLER_55_169 VGND VGND VPWR VPWR sky130_fd_sc_hd__decap_3
XFILLER_64_681 VGND VGND VPWR VPWR sky130_fd_sc_hd__decap_3
XFILLER_70_117 VGND VGND VPWR VPWR sky130_fd_sc_hd__fill_1
XFILLER_34_27 VGND VGND VPWR VPWR sky130_fd_sc_hd__fill_1
XFILLER_51_320 VGND VGND VPWR VPWR sky130_fd_sc_hd__decap_3
XFILLER_63_180 VGND VGND VPWR VPWR sky130_fd_sc_hd__fill_1
XFILLER_63_191 VGND VGND VPWR VPWR sky130_fd_sc_hd__decap_3
XFILLER_70_128 VGND VGND VPWR VPWR sky130_fd_sc_hd__decap_3
XFILLER_11_217 VGND VGND VPWR VPWR sky130_fd_sc_hd__decap_3
XFILLER_51_386 VGND VGND VPWR VPWR sky130_fd_sc_hd__decap_3
X_4978_ _5092_/C _4973_/X _4975_/Y _6993_/D _4997_/A1 VGND VGND VPWR VPWR _4978_/X
+ sky130_fd_sc_hd__a32o_2
XFILLER_109_105 VGND VGND VPWR VPWR sky130_fd_sc_hd__fill_1
Xclkload4 clkload4/A VGND VGND VPWR VPWR clkload4/Y sky130_fd_sc_hd__inv_4
X_6717_ _6966_/CLK _6717_/D VGND VGND VPWR VPWR _6717_/Q sky130_fd_sc_hd__dfxtp_2
XFILLER_109_116 VGND VGND VPWR VPWR sky130_fd_sc_hd__fill_2
X_6648_ _6682_/A VGND VGND VPWR VPWR _6648_/Y sky130_fd_sc_hd__inv_2
XFILLER_109_149 VGND VGND VPWR VPWR sky130_fd_sc_hd__fill_1
XFILLER_105_300 VGND VGND VPWR VPWR sky130_fd_sc_hd__fill_2
X_6579_ _6611_/A VGND VGND VPWR VPWR _6579_/Y sky130_fd_sc_hd__inv_2
XFILLER_105_333 VGND VGND VPWR VPWR sky130_fd_sc_hd__decap_3
XFILLER_3_449 VGND VGND VPWR VPWR sky130_fd_sc_hd__decap_3
XFILLER_59_57 VGND VGND VPWR VPWR sky130_fd_sc_hd__decap_3
XFILLER_78_206 VGND VGND VPWR VPWR sky130_fd_sc_hd__decap_3
XFILLER_105_388 VGND VGND VPWR VPWR sky130_fd_sc_hd__decap_3
XFILLER_105_399 VGND VGND VPWR VPWR sky130_fd_sc_hd__decap_3
XFILLER_59_420 VGND VGND VPWR VPWR sky130_fd_sc_hd__decap_3
XFILLER_115_52 VGND VGND VPWR VPWR sky130_fd_sc_hd__decap_3
XFILLER_115_63 VGND VGND VPWR VPWR sky130_fd_sc_hd__decap_3
XFILLER_75_12 VGND VGND VPWR VPWR sky130_fd_sc_hd__decap_3
XFILLER_101_561 VGND VGND VPWR VPWR sky130_fd_sc_hd__decap_3
XFILLER_115_96 VGND VGND VPWR VPWR sky130_fd_sc_hd__decap_3
XFILLER_19_317 VGND VGND VPWR VPWR sky130_fd_sc_hd__decap_3
XFILLER_47_626 VGND VGND VPWR VPWR sky130_fd_sc_hd__fill_2
XFILLER_74_412 VGND VGND VPWR VPWR sky130_fd_sc_hd__decap_3
XTAP_TAPCELL_ROW_70_1096 VGND VPWR sky130_fd_sc_hd__tapvpwrvgnd_1
XFILLER_46_136 VGND VGND VPWR VPWR sky130_fd_sc_hd__decap_3
XFILLER_46_147 VGND VGND VPWR VPWR sky130_fd_sc_hd__decap_3
XFILLER_74_434 VGND VGND VPWR VPWR sky130_fd_sc_hd__decap_3
XFILLER_27_361 VGND VGND VPWR VPWR sky130_fd_sc_hd__decap_3
XFILLER_34_309 VGND VGND VPWR VPWR sky130_fd_sc_hd__decap_3
XFILLER_54_180 VGND VGND VPWR VPWR sky130_fd_sc_hd__decap_3
XFILLER_91_22 VGND VGND VPWR VPWR sky130_fd_sc_hd__decap_3
XFILLER_15_578 VGND VGND VPWR VPWR sky130_fd_sc_hd__fill_1
XFILLER_30_504 VGND VGND VPWR VPWR sky130_fd_sc_hd__fill_1
XFILLER_70_651 VGND VGND VPWR VPWR sky130_fd_sc_hd__fill_1
XFILLER_91_55 VGND VGND VPWR VPWR sky130_fd_sc_hd__fill_1
XFILLER_91_66 VGND VGND VPWR VPWR sky130_fd_sc_hd__decap_3
XTAP_TAPCELL_ROW_25_551 VGND VPWR sky130_fd_sc_hd__tapvpwrvgnd_1
XTAP_TAPCELL_ROW_53_893 VGND VPWR sky130_fd_sc_hd__tapvpwrvgnd_1
XTAP_TAPCELL_ROW_53_882 VGND VPWR sky130_fd_sc_hd__tapvpwrvgnd_1
XFILLER_10_250 VGND VGND VPWR VPWR sky130_fd_sc_hd__fill_2
XFILLER_10_272 VGND VGND VPWR VPWR sky130_fd_sc_hd__decap_3
XFILLER_116_609 VGND VGND VPWR VPWR sky130_fd_sc_hd__decap_3
XFILLER_6_221 VGND VGND VPWR VPWR sky130_fd_sc_hd__fill_2
XFILLER_115_108 VGND VGND VPWR VPWR sky130_fd_sc_hd__decap_3
XFILLER_40_81 VGND VGND VPWR VPWR sky130_fd_sc_hd__decap_3
XFILLER_108_182 VGND VGND VPWR VPWR sky130_fd_sc_hd__decap_3
XFILLER_97_526 VGND VGND VPWR VPWR sky130_fd_sc_hd__decap_3
XFILLER_2_471 VGND VGND VPWR VPWR sky130_fd_sc_hd__fill_2
XFILLER_34_6 VGND VGND VPWR VPWR sky130_fd_sc_hd__decap_3
XFILLER_69_228 VGND VGND VPWR VPWR sky130_fd_sc_hd__decap_3
XFILLER_111_358 VGND VGND VPWR VPWR sky130_fd_sc_hd__decap_3
XFILLER_1_20 VGND VGND VPWR VPWR sky130_fd_sc_hd__decap_3
XFILLER_37_103 VGND VGND VPWR VPWR sky130_fd_sc_hd__decap_3
XFILLER_65_423 VGND VGND VPWR VPWR sky130_fd_sc_hd__decap_3
XTAP_TAPCELL_ROW_88_1313 VGND VPWR sky130_fd_sc_hd__tapvpwrvgnd_1
XTAP_TAPCELL_ROW_88_1302 VGND VPWR sky130_fd_sc_hd__tapvpwrvgnd_1
XFILLER_37_125 VGND VGND VPWR VPWR sky130_fd_sc_hd__decap_3
XFILLER_92_220 VGND VGND VPWR VPWR sky130_fd_sc_hd__decap_3
XFILLER_37_158 VGND VGND VPWR VPWR sky130_fd_sc_hd__decap_3
XFILLER_37_169 VGND VGND VPWR VPWR sky130_fd_sc_hd__decap_3
XFILLER_80_415 VGND VGND VPWR VPWR sky130_fd_sc_hd__fill_2
XFILLER_92_264 VGND VGND VPWR VPWR sky130_fd_sc_hd__decap_3
XFILLER_18_372 VGND VGND VPWR VPWR sky130_fd_sc_hd__decap_3
XFILLER_80_448 VGND VGND VPWR VPWR sky130_fd_sc_hd__decap_3
X_4901_ _4901_/A0 _4899_/X _5028_/S VGND VGND VPWR VPWR _7268_/D sky130_fd_sc_hd__mux2_2
XFILLER_33_364 VGND VGND VPWR VPWR sky130_fd_sc_hd__decap_3
XFILLER_45_191 VGND VGND VPWR VPWR sky130_fd_sc_hd__fill_2
XFILLER_33_386 VGND VGND VPWR VPWR sky130_fd_sc_hd__decap_3
X_4832_ _4832_/A _5657_/A VGND VGND VPWR VPWR _4832_/X sky130_fd_sc_hd__or2_2
X_4763_ _4762_/A _4762_/B _4948_/A VGND VGND VPWR VPWR _4763_/X sky130_fd_sc_hd__a21o_2
X_6502_ _6567_/A VGND VGND VPWR VPWR _6502_/Y sky130_fd_sc_hd__inv_2
X_4694_ _7008_/Q _4728_/A VGND VGND VPWR VPWR _4694_/Y sky130_fd_sc_hd__nor2_2
X_3714_ _3735_/A _3741_/B _3746_/C VGND VGND VPWR VPWR _3714_/X sky130_fd_sc_hd__and3_2
XTAP_TAPCELL_ROW_99_1442 VGND VPWR sky130_fd_sc_hd__tapvpwrvgnd_1
X_6433_ _6562_/A VGND VGND VPWR VPWR _6433_/Y sky130_fd_sc_hd__inv_2
XFILLER_106_119 VGND VGND VPWR VPWR sky130_fd_sc_hd__decap_3
XFILLER_20_29 VGND VGND VPWR VPWR sky130_fd_sc_hd__decap_3
X_3645_ hold976/X _4791_/A1 _4664_/B VGND VGND VPWR VPWR _7406_/D sky130_fd_sc_hd__a21o_2
X_6364_ _6366_/A VGND VGND VPWR VPWR _6364_/Y sky130_fd_sc_hd__inv_2
X_3576_ _7252_/Q _4601_/S _3377_/X _7220_/Q _3575_/X VGND VGND VPWR VPWR _3576_/Y
+ sky130_fd_sc_hd__a221oi_2
XFILLER_102_303 VGND VGND VPWR VPWR sky130_fd_sc_hd__decap_3
XFILLER_114_141 VGND VGND VPWR VPWR sky130_fd_sc_hd__decap_3
XFILLER_88_504 VGND VGND VPWR VPWR sky130_fd_sc_hd__decap_3
X_6295_ _6535_/A VGND VGND VPWR VPWR _6295_/Y sky130_fd_sc_hd__inv_2
X_5315_ _7173_/Q _4878_/X _5327_/S VGND VGND VPWR VPWR _7173_/D sky130_fd_sc_hd__mux2_2
XFILLER_102_336 VGND VGND VPWR VPWR sky130_fd_sc_hd__decap_3
XFILLER_88_548 VGND VGND VPWR VPWR sky130_fd_sc_hd__decap_3
XFILLER_29_38 VGND VGND VPWR VPWR sky130_fd_sc_hd__decap_3
XPHY_EDGE_ROW_89_Right_89 VGND VGND VPWR VPWR sky130_fd_sc_hd__decap_3
X_5177_ _5177_/A _5190_/B VGND VGND VPWR VPWR _7239_/D sky130_fd_sc_hd__and2_2
XFILLER_28_125 VGND VGND VPWR VPWR sky130_fd_sc_hd__decap_3
XFILLER_28_147 VGND VGND VPWR VPWR sky130_fd_sc_hd__decap_3
XFILLER_56_434 VGND VGND VPWR VPWR sky130_fd_sc_hd__decap_3
XFILLER_68_294 VGND VGND VPWR VPWR sky130_fd_sc_hd__decap_3
XFILLER_83_220 VGND VGND VPWR VPWR sky130_fd_sc_hd__decap_3
XFILLER_83_231 VGND VGND VPWR VPWR sky130_fd_sc_hd__decap_3
X_4128_ _7331_/Q _3956_/S _4190_/B1 _7139_/Q VGND VGND VPWR VPWR _4128_/X sky130_fd_sc_hd__a22o_2
XFILLER_16_309 VGND VGND VPWR VPWR sky130_fd_sc_hd__fill_2
XFILLER_43_106 VGND VGND VPWR VPWR sky130_fd_sc_hd__decap_3
XFILLER_45_26 VGND VGND VPWR VPWR sky130_fd_sc_hd__fill_2
XFILLER_56_489 VGND VGND VPWR VPWR sky130_fd_sc_hd__decap_3
X_4059_ _7276_/Q _4437_/A2 _4056_/X _4058_/X VGND VGND VPWR VPWR _4059_/X sky130_fd_sc_hd__a211o_2
XFILLER_43_128 VGND VGND VPWR VPWR sky130_fd_sc_hd__fill_2
XFILLER_101_32 VGND VGND VPWR VPWR sky130_fd_sc_hd__decap_3
XFILLER_101_43 VGND VGND VPWR VPWR sky130_fd_sc_hd__decap_3
XFILLER_24_331 VGND VGND VPWR VPWR sky130_fd_sc_hd__decap_3
XFILLER_36_191 VGND VGND VPWR VPWR sky130_fd_sc_hd__decap_3
XFILLER_12_515 VGND VGND VPWR VPWR sky130_fd_sc_hd__decap_3
XFILLER_12_526 VGND VGND VPWR VPWR sky130_fd_sc_hd__fill_1
XFILLER_24_397 VGND VGND VPWR VPWR sky130_fd_sc_hd__decap_3
XTAP_TAPCELL_ROW_22_510 VGND VPWR sky130_fd_sc_hd__tapvpwrvgnd_1
XPHY_EDGE_ROW_98_Right_98 VGND VGND VPWR VPWR sky130_fd_sc_hd__decap_3
XFILLER_101_87 VGND VGND VPWR VPWR sky130_fd_sc_hd__decap_3
XFILLER_51_194 VGND VGND VPWR VPWR sky130_fd_sc_hd__decap_3
XFILLER_61_36 VGND VGND VPWR VPWR sky130_fd_sc_hd__decap_3
XFILLER_8_519 VGND VGND VPWR VPWR sky130_fd_sc_hd__decap_3
XTAP_TAPCELL_ROW_50_852 VGND VPWR sky130_fd_sc_hd__tapvpwrvgnd_1
XTAP_TAPCELL_ROW_22_521 VGND VPWR sky130_fd_sc_hd__tapvpwrvgnd_1
XFILLER_61_69 VGND VGND VPWR VPWR sky130_fd_sc_hd__decap_3
XFILLER_20_592 VGND VGND VPWR VPWR sky130_fd_sc_hd__fill_1
XFILLER_3_213 VGND VGND VPWR VPWR sky130_fd_sc_hd__decap_3
XFILLER_105_130 VGND VGND VPWR VPWR sky130_fd_sc_hd__decap_3
XFILLER_10_40 VGND VGND VPWR VPWR sky130_fd_sc_hd__decap_3
XTAP_TAPCELL_ROW_72_1114 VGND VPWR sky130_fd_sc_hd__tapvpwrvgnd_1
XPHY_EDGE_ROW_5_Left_122 VGND VGND VPWR VPWR sky130_fd_sc_hd__decap_3
XFILLER_105_163 VGND VGND VPWR VPWR sky130_fd_sc_hd__decap_3
XFILLER_10_95 VGND VGND VPWR VPWR sky130_fd_sc_hd__decap_3
XFILLER_3_279 VGND VGND VPWR VPWR sky130_fd_sc_hd__fill_1
XFILLER_79_559 VGND VGND VPWR VPWR sky130_fd_sc_hd__fill_1
XFILLER_66_209 VGND VGND VPWR VPWR sky130_fd_sc_hd__decap_3
XFILLER_86_44 VGND VGND VPWR VPWR sky130_fd_sc_hd__decap_3
XFILLER_94_518 VGND VGND VPWR VPWR sky130_fd_sc_hd__decap_3
XFILLER_19_103 VGND VGND VPWR VPWR sky130_fd_sc_hd__decap_3
XFILLER_47_423 VGND VGND VPWR VPWR sky130_fd_sc_hd__decap_3
XFILLER_86_77 VGND VGND VPWR VPWR sky130_fd_sc_hd__decap_3
XFILLER_86_88 VGND VGND VPWR VPWR sky130_fd_sc_hd__decap_3
XFILLER_87_570 VGND VGND VPWR VPWR sky130_fd_sc_hd__decap_3
XFILLER_19_60 VGND VGND VPWR VPWR sky130_fd_sc_hd__decap_3
XTAP_TAPCELL_ROW_58_952 VGND VPWR sky130_fd_sc_hd__tapvpwrvgnd_1
XFILLER_19_158 VGND VGND VPWR VPWR sky130_fd_sc_hd__decap_3
XFILLER_19_169 VGND VGND VPWR VPWR sky130_fd_sc_hd__decap_3
XFILLER_74_242 VGND VGND VPWR VPWR sky130_fd_sc_hd__decap_3
XFILLER_74_253 VGND VGND VPWR VPWR sky130_fd_sc_hd__fill_2
XFILLER_34_117 VGND VGND VPWR VPWR sky130_fd_sc_hd__decap_3
XFILLER_62_448 VGND VGND VPWR VPWR sky130_fd_sc_hd__decap_3
XFILLER_15_331 VGND VGND VPWR VPWR sky130_fd_sc_hd__decap_3
XFILLER_35_70 VGND VGND VPWR VPWR sky130_fd_sc_hd__decap_3
XTAP_TAPCELL_ROW_83_1243 VGND VPWR sky130_fd_sc_hd__tapvpwrvgnd_1
XFILLER_15_364 VGND VGND VPWR VPWR sky130_fd_sc_hd__decap_3
XFILLER_15_375 VGND VGND VPWR VPWR sky130_fd_sc_hd__decap_3
XFILLER_30_301 VGND VGND VPWR VPWR sky130_fd_sc_hd__decap_3
XFILLER_35_81 VGND VGND VPWR VPWR sky130_fd_sc_hd__decap_3
XFILLER_43_673 VGND VGND VPWR VPWR sky130_fd_sc_hd__fill_2
XFILLER_70_492 VGND VGND VPWR VPWR sky130_fd_sc_hd__decap_3
XFILLER_30_356 VGND VGND VPWR VPWR sky130_fd_sc_hd__decap_3
XFILLER_30_389 VGND VGND VPWR VPWR sky130_fd_sc_hd__decap_3
XFILLER_116_417 VGND VGND VPWR VPWR sky130_fd_sc_hd__decap_3
XFILLER_7_596 VGND VGND VPWR VPWR sky130_fd_sc_hd__fill_2
X_3361_ _3386_/A _3386_/B VGND VGND VPWR VPWR _3376_/B sky130_fd_sc_hd__and2_2
XTAP_TAPCELL_ROW_94_1383 VGND VPWR sky130_fd_sc_hd__tapvpwrvgnd_1
XFILLER_32_3 VGND VGND VPWR VPWR sky130_fd_sc_hd__decap_3
X_5100_ _5100_/A _5100_/B VGND VGND VPWR VPWR _5100_/Y sky130_fd_sc_hd__xnor2_2
XFILLER_111_122 VGND VGND VPWR VPWR sky130_fd_sc_hd__decap_3
XFILLER_111_144 VGND VGND VPWR VPWR sky130_fd_sc_hd__fill_1
XFILLER_112_645 VGND VGND VPWR VPWR sky130_fd_sc_hd__decap_3
X_5031_ _5032_/A _5031_/B VGND VGND VPWR VPWR _5031_/X sky130_fd_sc_hd__xor2_2
XFILLER_111_166 VGND VGND VPWR VPWR sky130_fd_sc_hd__fill_2
XFILLER_112_689 VGND VGND VPWR VPWR sky130_fd_sc_hd__decap_3
Xhold1208 _7329_/Q VGND VGND VPWR VPWR _4501_/A0 sky130_fd_sc_hd__dlygate4sd3_1
XFILLER_38_434 VGND VGND VPWR VPWR sky130_fd_sc_hd__decap_3
XFILLER_65_220 VGND VGND VPWR VPWR sky130_fd_sc_hd__decap_3
XFILLER_65_231 VGND VGND VPWR VPWR sky130_fd_sc_hd__decap_3
XFILLER_78_592 VGND VGND VPWR VPWR sky130_fd_sc_hd__decap_3
XFILLER_65_242 VGND VGND VPWR VPWR sky130_fd_sc_hd__decap_3
XFILLER_65_275 VGND VGND VPWR VPWR sky130_fd_sc_hd__decap_3
XPHY_EDGE_ROW_69_Left_186 VGND VGND VPWR VPWR sky130_fd_sc_hd__decap_3
XFILLER_25_128 VGND VGND VPWR VPWR sky130_fd_sc_hd__decap_3
XFILLER_80_234 VGND VGND VPWR VPWR sky130_fd_sc_hd__decap_3
X_6982_ _7364_/CLK _6982_/D _6262_/Y VGND VGND VPWR VPWR _6982_/Q sky130_fd_sc_hd__dfrtp_2
XTAP_TAPCELL_ROW_0_249 VGND VPWR sky130_fd_sc_hd__tapvpwrvgnd_1
XTAP_TAPCELL_ROW_0_238 VGND VPWR sky130_fd_sc_hd__tapvpwrvgnd_1
XFILLER_15_18 VGND VGND VPWR VPWR sky130_fd_sc_hd__decap_3
XFILLER_80_256 VGND VGND VPWR VPWR sky130_fd_sc_hd__decap_3
XFILLER_33_150 VGND VGND VPWR VPWR sky130_fd_sc_hd__decap_3
XFILLER_33_172 VGND VGND VPWR VPWR sky130_fd_sc_hd__decap_3
XFILLER_40_109 VGND VGND VPWR VPWR sky130_fd_sc_hd__decap_3
XFILLER_61_470 VGND VGND VPWR VPWR sky130_fd_sc_hd__decap_3
XFILLER_80_289 VGND VGND VPWR VPWR sky130_fd_sc_hd__decap_3
XTAP_TAPCELL_ROW_36_679 VGND VPWR sky130_fd_sc_hd__tapvpwrvgnd_1
X_4815_ _4812_/Y _4813_/Y _4814_/Y _4779_/X VGND VGND VPWR VPWR _4815_/X sky130_fd_sc_hd__o211a_2
XTAP_TAPCELL_ROW_103_1490 VGND VPWR sky130_fd_sc_hd__tapvpwrvgnd_1
XFILLER_31_28 VGND VGND VPWR VPWR sky130_fd_sc_hd__decap_3
X_4746_ _4764_/B _4069_/B _4744_/Y _4745_/Y _4852_/A VGND VGND VPWR VPWR _4746_/X
+ sky130_fd_sc_hd__o32a_2
X_4677_ _6989_/Q _4677_/B VGND VGND VPWR VPWR _5036_/A sky130_fd_sc_hd__and2_2
XPHY_EDGE_ROW_78_Left_195 VGND VGND VPWR VPWR sky130_fd_sc_hd__decap_3
XFILLER_103_9 VGND VGND VPWR VPWR sky130_fd_sc_hd__fill_2
X_7396_ _7396_/CLK _7396_/D _6676_/Y VGND VGND VPWR VPWR _7396_/Q sky130_fd_sc_hd__dfrtp_2
X_6416_ _6608_/A VGND VGND VPWR VPWR _6416_/Y sky130_fd_sc_hd__inv_2
X_6347_ _6347_/A VGND VGND VPWR VPWR _6347_/Y sky130_fd_sc_hd__inv_2
XFILLER_103_623 VGND VGND VPWR VPWR sky130_fd_sc_hd__decap_3
XFILLER_88_312 VGND VGND VPWR VPWR sky130_fd_sc_hd__decap_3
X_3559_ _3553_/X _3557_/X _3558_/X _3590_/A VGND VGND VPWR VPWR _4295_/B sky130_fd_sc_hd__o211a_2
XTAP_TAPCELL_ROW_8_349 VGND VPWR sky130_fd_sc_hd__tapvpwrvgnd_1
XFILLER_102_144 VGND VGND VPWR VPWR sky130_fd_sc_hd__fill_1
XFILLER_76_507 VGND VGND VPWR VPWR sky130_fd_sc_hd__decap_3
XFILLER_88_356 VGND VGND VPWR VPWR sky130_fd_sc_hd__decap_3
X_6278_ _6652_/A VGND VGND VPWR VPWR _6278_/Y sky130_fd_sc_hd__inv_2
XFILLER_102_155 VGND VGND VPWR VPWR sky130_fd_sc_hd__decap_3
X_5229_ _5362_/C _5229_/B _5229_/C VGND VGND VPWR VPWR _5245_/S sky130_fd_sc_hd__and3b_2
XFILLER_29_434 VGND VGND VPWR VPWR sky130_fd_sc_hd__decap_3
XFILLER_56_47 VGND VGND VPWR VPWR sky130_fd_sc_hd__decap_3
XFILLER_56_253 VGND VGND VPWR VPWR sky130_fd_sc_hd__decap_3
XFILLER_84_551 VGND VGND VPWR VPWR sky130_fd_sc_hd__decap_3
XTAP_TAPCELL_ROW_55_911 VGND VPWR sky130_fd_sc_hd__tapvpwrvgnd_1
XFILLER_16_128 VGND VGND VPWR VPWR sky130_fd_sc_hd__decap_3
XFILLER_44_415 VGND VGND VPWR VPWR sky130_fd_sc_hd__decap_3
XFILLER_56_286 VGND VGND VPWR VPWR sky130_fd_sc_hd__decap_3
XFILLER_84_595 VGND VGND VPWR VPWR sky130_fd_sc_hd__decap_3
XTAP_TAPCELL_ROW_106_1519 VGND VPWR sky130_fd_sc_hd__tapvpwrvgnd_1
XFILLER_44_459 VGND VGND VPWR VPWR sky130_fd_sc_hd__decap_3
XFILLER_71_234 VGND VGND VPWR VPWR sky130_fd_sc_hd__decap_3
XFILLER_71_267 VGND VGND VPWR VPWR sky130_fd_sc_hd__decap_3
XFILLER_72_24 VGND VGND VPWR VPWR sky130_fd_sc_hd__decap_3
XFILLER_112_97 VGND VGND VPWR VPWR sky130_fd_sc_hd__decap_3
XFILLER_12_301 VGND VGND VPWR VPWR sky130_fd_sc_hd__decap_3
XFILLER_12_312 VGND VGND VPWR VPWR sky130_fd_sc_hd__decap_3
XFILLER_25_673 VGND VGND VPWR VPWR sky130_fd_sc_hd__decap_3
XFILLER_4_500 VGND VGND VPWR VPWR sky130_fd_sc_hd__fill_2
XFILLER_21_83 VGND VGND VPWR VPWR sky130_fd_sc_hd__decap_3
XFILLER_4_544 VGND VGND VPWR VPWR sky130_fd_sc_hd__decap_3
XFILLER_4_555 VGND VGND VPWR VPWR sky130_fd_sc_hd__decap_3
XFILLER_97_21 VGND VGND VPWR VPWR sky130_fd_sc_hd__decap_3
XFILLER_106_483 VGND VGND VPWR VPWR sky130_fd_sc_hd__fill_1
XFILLER_79_312 VGND VGND VPWR VPWR sky130_fd_sc_hd__decap_3
XFILLER_97_54 VGND VGND VPWR VPWR sky130_fd_sc_hd__fill_2
XFILLER_67_529 VGND VGND VPWR VPWR sky130_fd_sc_hd__decap_3
XFILLER_79_378 VGND VGND VPWR VPWR sky130_fd_sc_hd__decap_3
XFILLER_94_315 VGND VGND VPWR VPWR sky130_fd_sc_hd__decap_3
XFILLER_47_231 VGND VGND VPWR VPWR sky130_fd_sc_hd__decap_3
XFILLER_75_540 VGND VGND VPWR VPWR sky130_fd_sc_hd__decap_3
XFILLER_94_348 VGND VGND VPWR VPWR sky130_fd_sc_hd__decap_3
XFILLER_47_264 VGND VGND VPWR VPWR sky130_fd_sc_hd__decap_3
XFILLER_75_573 VGND VGND VPWR VPWR sky130_fd_sc_hd__decap_3
XFILLER_35_437 VGND VGND VPWR VPWR sky130_fd_sc_hd__fill_1
XFILLER_62_201 VGND VGND VPWR VPWR sky130_fd_sc_hd__decap_3
XFILLER_16_640 VGND VGND VPWR VPWR sky130_fd_sc_hd__decap_3
XFILLER_62_234 VGND VGND VPWR VPWR sky130_fd_sc_hd__decap_3
XFILLER_90_565 VGND VGND VPWR VPWR sky130_fd_sc_hd__decap_3
XFILLER_15_150 VGND VGND VPWR VPWR sky130_fd_sc_hd__decap_3
XFILLER_22_109 VGND VGND VPWR VPWR sky130_fd_sc_hd__decap_3
XFILLER_15_172 VGND VGND VPWR VPWR sky130_fd_sc_hd__decap_3
XFILLER_30_120 VGND VGND VPWR VPWR sky130_fd_sc_hd__decap_3
XFILLER_31_643 VGND VGND VPWR VPWR sky130_fd_sc_hd__decap_3
XTAP_TAPCELL_ROW_33_649 VGND VPWR sky130_fd_sc_hd__tapvpwrvgnd_1
XFILLER_30_153 VGND VGND VPWR VPWR sky130_fd_sc_hd__decap_3
XFILLER_30_186 VGND VGND VPWR VPWR sky130_fd_sc_hd__decap_3
XFILLER_30_197 VGND VGND VPWR VPWR sky130_fd_sc_hd__fill_1
XTAP_TAPCELL_ROW_96_1401 VGND VPWR sky130_fd_sc_hd__tapvpwrvgnd_1
XFILLER_116_203 VGND VGND VPWR VPWR sky130_fd_sc_hd__decap_3
XFILLER_7_63 VGND VGND VPWR VPWR sky130_fd_sc_hd__decap_3
XFILLER_116_225 VGND VGND VPWR VPWR sky130_fd_sc_hd__decap_3
XFILLER_7_96 VGND VGND VPWR VPWR sky130_fd_sc_hd__fill_1
X_7250_ clkload8/A _7250_/D _6530_/Y VGND VGND VPWR VPWR _7250_/Q sky130_fd_sc_hd__dfrtp_2
X_4462_ _3621_/B _3618_/X _3541_/X VGND VGND VPWR VPWR _4462_/Y sky130_fd_sc_hd__o21ai_2
XFILLER_104_409 VGND VGND VPWR VPWR sky130_fd_sc_hd__fill_2
X_3413_ _7155_/Q _4334_/B1 _3410_/X _3412_/X VGND VGND VPWR VPWR _3413_/X sky130_fd_sc_hd__a211o_2
X_7181_ _7340_/CLK _7181_/D _6461_/Y VGND VGND VPWR VPWR _7181_/Q sky130_fd_sc_hd__dfrtp_2
X_4393_ _7305_/Q _4879_/S _4434_/A2 _7113_/Q _4392_/X VGND VGND VPWR VPWR _4393_/X
+ sky130_fd_sc_hd__a221o_2
X_3344_ _3519_/B _5118_/D VGND VGND VPWR VPWR _3344_/Y sky130_fd_sc_hd__nor2_2
XTAP_TAPCELL_ROW_5_308 VGND VPWR sky130_fd_sc_hd__tapvpwrvgnd_1
XFILLER_112_486 VGND VGND VPWR VPWR sky130_fd_sc_hd__decap_3
XFILLER_97_175 VGND VGND VPWR VPWR sky130_fd_sc_hd__decap_3
Xhold1005 _7231_/Q VGND VGND VPWR VPWR _5194_/A sky130_fd_sc_hd__dlygate4sd3_1
XFILLER_100_637 VGND VGND VPWR VPWR sky130_fd_sc_hd__decap_3
XFILLER_85_337 VGND VGND VPWR VPWR sky130_fd_sc_hd__decap_3
Xhold1016 _7045_/Q VGND VGND VPWR VPWR _5572_/A1 sky130_fd_sc_hd__dlygate4sd3_1
Xhold1027 _7254_/Q VGND VGND VPWR VPWR _5122_/A0 sky130_fd_sc_hd__dlygate4sd3_1
Xhold1038 _7202_/Q VGND VGND VPWR VPWR _5256_/A0 sky130_fd_sc_hd__dlygate4sd3_1
Xhold1049 _7204_/Q VGND VGND VPWR VPWR _5251_/A0 sky130_fd_sc_hd__dlygate4sd3_1
X_5014_ _6990_/Q _5014_/B VGND VGND VPWR VPWR _5015_/C sky130_fd_sc_hd__or2_2
XFILLER_26_404 VGND VGND VPWR VPWR sky130_fd_sc_hd__decap_3
XFILLER_38_242 VGND VGND VPWR VPWR sky130_fd_sc_hd__decap_3
XFILLER_38_253 VGND VGND VPWR VPWR sky130_fd_sc_hd__decap_3
XFILLER_66_551 VGND VGND VPWR VPWR sky130_fd_sc_hd__decap_3
XFILLER_81_532 VGND VGND VPWR VPWR sky130_fd_sc_hd__decap_3
XFILLER_93_370 VGND VGND VPWR VPWR sky130_fd_sc_hd__decap_3
XFILLER_53_234 VGND VGND VPWR VPWR sky130_fd_sc_hd__decap_3
X_6965_ _6965_/CLK _6965_/D VGND VGND VPWR VPWR _6965_/Q sky130_fd_sc_hd__dfxtp_2
XFILLER_53_278 VGND VGND VPWR VPWR sky130_fd_sc_hd__fill_2
X_6896_ _7198_/CLK _6896_/D VGND VGND VPWR VPWR _6896_/Q sky130_fd_sc_hd__dfxtp_2
XFILLER_21_142 VGND VGND VPWR VPWR sky130_fd_sc_hd__decap_3
XFILLER_21_175 VGND VGND VPWR VPWR sky130_fd_sc_hd__decap_3
XPHY_EDGE_ROW_86_Left_203 VGND VGND VPWR VPWR sky130_fd_sc_hd__decap_3
XFILLER_5_308 VGND VGND VPWR VPWR sky130_fd_sc_hd__decap_3
X_4729_ _4836_/S _4729_/B VGND VGND VPWR VPWR _4729_/Y sky130_fd_sc_hd__nand2_2
XFILLER_107_214 VGND VGND VPWR VPWR sky130_fd_sc_hd__decap_3
XFILLER_107_225 VGND VGND VPWR VPWR sky130_fd_sc_hd__decap_3
XFILLER_107_20 VGND VGND VPWR VPWR sky130_fd_sc_hd__decap_3
XFILLER_89_632 VGND VGND VPWR VPWR sky130_fd_sc_hd__decap_3
X_7379_ _7384_/CLK _7379_/D _6659_/Y VGND VGND VPWR VPWR _7379_/Q sky130_fd_sc_hd__dfrtp_2
Xhold850 _7089_/Q VGND VGND VPWR VPWR _7089_/D sky130_fd_sc_hd__dlygate4sd3_1
Xhold861 _7101_/Q VGND VGND VPWR VPWR _7101_/D sky130_fd_sc_hd__dlygate4sd3_1
Xhold872 _7056_/Q VGND VGND VPWR VPWR _7056_/D sky130_fd_sc_hd__dlygate4sd3_1
Xmax_cap580 _6462_/A VGND VGND VPWR VPWR _6652_/A sky130_fd_sc_hd__buf_2
XFILLER_107_75 VGND VGND VPWR VPWR sky130_fd_sc_hd__decap_3
XFILLER_1_558 VGND VGND VPWR VPWR sky130_fd_sc_hd__fill_2
XFILLER_88_120 VGND VGND VPWR VPWR sky130_fd_sc_hd__decap_3
XFILLER_89_665 VGND VGND VPWR VPWR sky130_fd_sc_hd__decap_3
Xhold883 _7084_/Q VGND VGND VPWR VPWR _7084_/D sky130_fd_sc_hd__dlygate4sd3_1
Xhold894 _7108_/Q VGND VGND VPWR VPWR _7108_/D sky130_fd_sc_hd__dlygate4sd3_1
XFILLER_103_486 VGND VGND VPWR VPWR sky130_fd_sc_hd__fill_1
XFILLER_88_153 VGND VGND VPWR VPWR sky130_fd_sc_hd__decap_3
XFILLER_89_676 VGND VGND VPWR VPWR sky130_fd_sc_hd__decap_3
XPHY_EDGE_ROW_95_Left_212 VGND VGND VPWR VPWR sky130_fd_sc_hd__decap_3
XFILLER_67_79 VGND VGND VPWR VPWR sky130_fd_sc_hd__fill_1
XFILLER_88_197 VGND VGND VPWR VPWR sky130_fd_sc_hd__fill_2
XFILLER_29_231 VGND VGND VPWR VPWR sky130_fd_sc_hd__decap_3
XFILLER_44_212 VGND VGND VPWR VPWR sky130_fd_sc_hd__decap_3
XFILLER_83_23 VGND VGND VPWR VPWR sky130_fd_sc_hd__decap_3
XFILLER_91_329 VGND VGND VPWR VPWR sky130_fd_sc_hd__decap_3
XFILLER_44_256 VGND VGND VPWR VPWR sky130_fd_sc_hd__decap_3
XTAP_TAPCELL_ROW_67_1057 VGND VPWR sky130_fd_sc_hd__tapvpwrvgnd_1
XFILLER_25_470 VGND VGND VPWR VPWR sky130_fd_sc_hd__decap_3
XFILLER_32_407 VGND VGND VPWR VPWR sky130_fd_sc_hd__decap_3
XFILLER_44_289 VGND VGND VPWR VPWR sky130_fd_sc_hd__fill_2
XFILLER_72_587 VGND VGND VPWR VPWR sky130_fd_sc_hd__fill_1
XFILLER_83_89 VGND VGND VPWR VPWR sky130_fd_sc_hd__decap_3
XFILLER_16_72 VGND VGND VPWR VPWR sky130_fd_sc_hd__decap_3
XTAP_TAPCELL_ROW_80_1213 VGND VPWR sky130_fd_sc_hd__tapvpwrvgnd_1
XFILLER_40_462 VGND VGND VPWR VPWR sky130_fd_sc_hd__fill_1
XTAP_TAPCELL_ROW_30_608 VGND VPWR sky130_fd_sc_hd__tapvpwrvgnd_1
XFILLER_12_175 VGND VGND VPWR VPWR sky130_fd_sc_hd__decap_3
XFILLER_12_186 VGND VGND VPWR VPWR sky130_fd_sc_hd__decap_3
XFILLER_40_495 VGND VGND VPWR VPWR sky130_fd_sc_hd__decap_3
XFILLER_12_197 VGND VGND VPWR VPWR sky130_fd_sc_hd__decap_3
XFILLER_32_82 VGND VGND VPWR VPWR sky130_fd_sc_hd__fill_2
XFILLER_8_168 VGND VGND VPWR VPWR sky130_fd_sc_hd__decap_3
XFILLER_66_9 VGND VGND VPWR VPWR sky130_fd_sc_hd__fill_2
XTAP_TAPCELL_ROW_10_376 VGND VPWR sky130_fd_sc_hd__tapvpwrvgnd_1
XFILLER_4_330 VGND VGND VPWR VPWR sky130_fd_sc_hd__decap_3
XTAP_TAPCELL_ROW_78_1186 VGND VPWR sky130_fd_sc_hd__tapvpwrvgnd_1
XFILLER_4_363 VGND VGND VPWR VPWR sky130_fd_sc_hd__fill_1
XFILLER_4_374 VGND VGND VPWR VPWR sky130_fd_sc_hd__decap_3
XFILLER_99_429 VGND VGND VPWR VPWR sky130_fd_sc_hd__decap_3
XFILLER_106_291 VGND VGND VPWR VPWR sky130_fd_sc_hd__decap_3
XTAP_TAPCELL_ROW_91_1342 VGND VPWR sky130_fd_sc_hd__tapvpwrvgnd_1
XFILLER_79_164 VGND VGND VPWR VPWR sky130_fd_sc_hd__decap_3
XFILLER_79_175 VGND VGND VPWR VPWR sky130_fd_sc_hd__decap_3
XFILLER_67_337 VGND VGND VPWR VPWR sky130_fd_sc_hd__decap_3
XFILLER_95_679 VGND VGND VPWR VPWR sky130_fd_sc_hd__decap_3
XTAP_TAPCELL_ROW_38_708 VGND VPWR sky130_fd_sc_hd__tapvpwrvgnd_1
XFILLER_35_201 VGND VGND VPWR VPWR sky130_fd_sc_hd__decap_3
XFILLER_75_370 VGND VGND VPWR VPWR sky130_fd_sc_hd__fill_1
XFILLER_94_189 VGND VGND VPWR VPWR sky130_fd_sc_hd__decap_3
XFILLER_35_245 VGND VGND VPWR VPWR sky130_fd_sc_hd__decap_3
XFILLER_63_543 VGND VGND VPWR VPWR sky130_fd_sc_hd__decap_3
XFILLER_63_587 VGND VGND VPWR VPWR sky130_fd_sc_hd__decap_3
XFILLER_90_351 VGND VGND VPWR VPWR sky130_fd_sc_hd__decap_3
X_6750_ _6978_/CLK _6750_/D VGND VGND VPWR VPWR _6750_/Q sky130_fd_sc_hd__dfxtp_2
XTAP_TAPCELL_ROW_18_465 VGND VPWR sky130_fd_sc_hd__tapvpwrvgnd_1
XFILLER_50_226 VGND VGND VPWR VPWR sky130_fd_sc_hd__decap_3
X_5701_ _7356_/Q hold943/X _5706_/S VGND VGND VPWR VPWR _6700_/D sky130_fd_sc_hd__mux2_2
X_3962_ _7359_/Q _4505_/A0 _3964_/S VGND VGND VPWR VPWR _7359_/D sky130_fd_sc_hd__mux2_2
X_6681_ _6682_/A VGND VGND VPWR VPWR _6681_/Y sky130_fd_sc_hd__inv_2
X_3893_ _6759_/Q _3893_/A2 _3656_/Y _6753_/Q _3892_/X VGND VGND VPWR VPWR _3893_/X
+ sky130_fd_sc_hd__a221o_2
X_5632_ _5632_/A VGND VGND VPWR VPWR _5633_/A sky130_fd_sc_hd__inv_2
X_5563_ hold980/X _5647_/A _4729_/B VGND VGND VPWR VPWR _7053_/D sky130_fd_sc_hd__a21bo_2
X_7302_ _7393_/CLK _7302_/D _6582_/Y VGND VGND VPWR VPWR _7302_/Q sky130_fd_sc_hd__dfrtp_2
XFILLER_7_190 VGND VGND VPWR VPWR sky130_fd_sc_hd__decap_3
XFILLER_104_228 VGND VGND VPWR VPWR sky130_fd_sc_hd__decap_3
X_7233_ _7363_/CLK _7233_/D _6513_/Y VGND VGND VPWR VPWR _7233_/Q sky130_fd_sc_hd__dfrtp_2
X_4445_ _4813_/A _4813_/B VGND VGND VPWR VPWR _4814_/B sky130_fd_sc_hd__nor2_2
X_7164_ _7294_/CLK _7164_/D _6444_/Y VGND VGND VPWR VPWR _7164_/Q sky130_fd_sc_hd__dfrtp_2
X_4376_ _4376_/A _4376_/B _4376_/C _4273_/D VGND VGND VPWR VPWR _4376_/X sky130_fd_sc_hd__or4b_2
XFILLER_100_401 VGND VGND VPWR VPWR sky130_fd_sc_hd__decap_3
XFILLER_86_624 VGND VGND VPWR VPWR sky130_fd_sc_hd__decap_3
X_3327_ _3327_/A _3353_/A VGND VGND VPWR VPWR _3328_/B sky130_fd_sc_hd__nor2_2
XFILLER_112_283 VGND VGND VPWR VPWR sky130_fd_sc_hd__decap_3
XFILLER_58_326 VGND VGND VPWR VPWR sky130_fd_sc_hd__decap_3
XFILLER_86_657 VGND VGND VPWR VPWR sky130_fd_sc_hd__fill_1
X_7095_ clkload4/A _7095_/D _6375_/Y VGND VGND VPWR VPWR _7095_/Q sky130_fd_sc_hd__dfrtp_2
XFILLER_98_495 VGND VGND VPWR VPWR sky130_fd_sc_hd__decap_3
XFILLER_100_445 VGND VGND VPWR VPWR sky130_fd_sc_hd__decap_3
XFILLER_37_27 VGND VGND VPWR VPWR sky130_fd_sc_hd__decap_3
XFILLER_37_49 VGND VGND VPWR VPWR sky130_fd_sc_hd__decap_3
XFILLER_58_359 VGND VGND VPWR VPWR sky130_fd_sc_hd__fill_2
XFILLER_73_307 VGND VGND VPWR VPWR sky130_fd_sc_hd__decap_3
XFILLER_85_145 VGND VGND VPWR VPWR sky130_fd_sc_hd__decap_3
XFILLER_100_489 VGND VGND VPWR VPWR sky130_fd_sc_hd__decap_3
XFILLER_26_212 VGND VGND VPWR VPWR sky130_fd_sc_hd__decap_3
XFILLER_54_521 VGND VGND VPWR VPWR sky130_fd_sc_hd__fill_2
XFILLER_81_340 VGND VGND VPWR VPWR sky130_fd_sc_hd__decap_3
XFILLER_26_278 VGND VGND VPWR VPWR sky130_fd_sc_hd__decap_3
XFILLER_41_215 VGND VGND VPWR VPWR sky130_fd_sc_hd__decap_3
XFILLER_53_15 VGND VGND VPWR VPWR sky130_fd_sc_hd__decap_3
XFILLER_81_373 VGND VGND VPWR VPWR sky130_fd_sc_hd__decap_3
XFILLER_53_48 VGND VGND VPWR VPWR sky130_fd_sc_hd__decap_3
X_6948_ _6966_/CLK _6948_/D VGND VGND VPWR VPWR _6948_/Q sky130_fd_sc_hd__dfxtp_2
XFILLER_22_451 VGND VGND VPWR VPWR sky130_fd_sc_hd__fill_1
XFILLER_41_259 VGND VGND VPWR VPWR sky130_fd_sc_hd__decap_3
X_6879_ _7390_/CLK _6879_/D VGND VGND VPWR VPWR _6879_/Q sky130_fd_sc_hd__dfxtp_2
XFILLER_22_473 VGND VGND VPWR VPWR sky130_fd_sc_hd__decap_3
XFILLER_5_116 VGND VGND VPWR VPWR sky130_fd_sc_hd__decap_3
XFILLER_108_545 VGND VGND VPWR VPWR sky130_fd_sc_hd__decap_3
XFILLER_5_149 VGND VGND VPWR VPWR sky130_fd_sc_hd__decap_3
XTAP_TAPCELL_ROW_114_1618 VGND VPWR sky130_fd_sc_hd__tapvpwrvgnd_1
XFILLER_108_589 VGND VGND VPWR VPWR sky130_fd_sc_hd__decap_3
XFILLER_78_23 VGND VGND VPWR VPWR sky130_fd_sc_hd__decap_3
Xhold680 _6900_/Q VGND VGND VPWR VPWR _6900_/D sky130_fd_sc_hd__dlygate4sd3_1
XFILLER_49_315 VGND VGND VPWR VPWR sky130_fd_sc_hd__decap_3
XFILLER_77_613 VGND VGND VPWR VPWR sky130_fd_sc_hd__decap_3
XFILLER_89_473 VGND VGND VPWR VPWR sky130_fd_sc_hd__decap_3
Xhold691 _6826_/Q VGND VGND VPWR VPWR _6826_/D sky130_fd_sc_hd__dlygate4sd3_1
XFILLER_49_337 VGND VGND VPWR VPWR sky130_fd_sc_hd__decap_3
XFILLER_92_616 VGND VGND VPWR VPWR sky130_fd_sc_hd__decap_3
XFILLER_94_44 VGND VGND VPWR VPWR sky130_fd_sc_hd__decap_3
XFILLER_45_521 VGND VGND VPWR VPWR sky130_fd_sc_hd__decap_3
XFILLER_57_370 VGND VGND VPWR VPWR sky130_fd_sc_hd__decap_3
XFILLER_76_189 VGND VGND VPWR VPWR sky130_fd_sc_hd__decap_3
XFILLER_17_223 VGND VGND VPWR VPWR sky130_fd_sc_hd__fill_1
XFILLER_17_245 VGND VGND VPWR VPWR sky130_fd_sc_hd__decap_3
XFILLER_27_60 VGND VGND VPWR VPWR sky130_fd_sc_hd__decap_3
XFILLER_91_159 VGND VGND VPWR VPWR sky130_fd_sc_hd__decap_3
XFILLER_94_88 VGND VGND VPWR VPWR sky130_fd_sc_hd__decap_3
XFILLER_27_93 VGND VGND VPWR VPWR sky130_fd_sc_hd__fill_2
XFILLER_32_204 VGND VGND VPWR VPWR sky130_fd_sc_hd__decap_3
XFILLER_60_513 VGND VGND VPWR VPWR sky130_fd_sc_hd__decap_3
XFILLER_72_395 VGND VGND VPWR VPWR sky130_fd_sc_hd__decap_3
XTAP_TAPCELL_ROW_15_435 VGND VPWR sky130_fd_sc_hd__tapvpwrvgnd_1
XTAP_TAPCELL_ROW_43_766 VGND VPWR sky130_fd_sc_hd__tapvpwrvgnd_1
XFILLER_13_495 VGND VGND VPWR VPWR sky130_fd_sc_hd__decap_3
XFILLER_43_92 VGND VGND VPWR VPWR sky130_fd_sc_hd__fill_2
XFILLER_64_6 VGND VGND VPWR VPWR sky130_fd_sc_hd__decap_3
XFILLER_114_504 VGND VGND VPWR VPWR sky130_fd_sc_hd__decap_3
XFILLER_4_182 VGND VGND VPWR VPWR sky130_fd_sc_hd__decap_3
XFILLER_4_20 VGND VGND VPWR VPWR sky130_fd_sc_hd__decap_3
XFILLER_4_42 VGND VGND VPWR VPWR sky130_fd_sc_hd__decap_3
X_4230_ _7227_/Q _4307_/A2 _5159_/S _7291_/Q _4229_/X VGND VGND VPWR VPWR _4230_/X
+ sky130_fd_sc_hd__a221o_2
XFILLER_99_237 VGND VGND VPWR VPWR sky130_fd_sc_hd__decap_3
X_4161_ _7265_/Q _4422_/A2 _4349_/B1 _7233_/Q _4160_/X VGND VGND VPWR VPWR _4161_/X
+ sky130_fd_sc_hd__a221o_2
XFILLER_68_624 VGND VGND VPWR VPWR sky130_fd_sc_hd__fill_2
XFILLER_68_635 VGND VGND VPWR VPWR sky130_fd_sc_hd__decap_3
XFILLER_68_657 VGND VGND VPWR VPWR sky130_fd_sc_hd__decap_3
XFILLER_67_156 VGND VGND VPWR VPWR sky130_fd_sc_hd__decap_3
XFILLER_95_476 VGND VGND VPWR VPWR sky130_fd_sc_hd__decap_3
X_4092_ _7366_/Q _4435_/B1 _4436_/B1 _7174_/Q _4091_/X VGND VGND VPWR VPWR _4092_/X
+ sky130_fd_sc_hd__a221o_2
XFILLER_83_649 VGND VGND VPWR VPWR sky130_fd_sc_hd__decap_3
XFILLER_63_340 VGND VGND VPWR VPWR sky130_fd_sc_hd__decap_3
XFILLER_82_137 VGND VGND VPWR VPWR sky130_fd_sc_hd__decap_3
XFILLER_82_159 VGND VGND VPWR VPWR sky130_fd_sc_hd__decap_3
XFILLER_63_373 VGND VGND VPWR VPWR sky130_fd_sc_hd__decap_3
Xplace340 _5398_/S VGND VGND VPWR VPWR _5383_/S sky130_fd_sc_hd__buf_2
X_6802_ _6966_/CLK _6802_/D VGND VGND VPWR VPWR _6802_/Q sky130_fd_sc_hd__dfxtp_2
XFILLER_90_181 VGND VGND VPWR VPWR sky130_fd_sc_hd__decap_3
Xplace373 _5151_/A VGND VGND VPWR VPWR _5138_/S sky130_fd_sc_hd__buf_2
Xplace362 _4267_/B1 VGND VGND VPWR VPWR _4436_/B1 sky130_fd_sc_hd__buf_2
Xplace351 _4218_/A2 VGND VGND VPWR VPWR _4434_/A2 sky130_fd_sc_hd__buf_2
X_4994_ _3604_/B _4994_/A2 _4987_/A _5033_/B2 VGND VGND VPWR VPWR _4994_/X sky130_fd_sc_hd__a22o_2
XFILLER_23_18 VGND VGND VPWR VPWR sky130_fd_sc_hd__decap_3
XFILLER_51_557 VGND VGND VPWR VPWR sky130_fd_sc_hd__decap_3
Xplace384 _4246_/B1 VGND VGND VPWR VPWR _4348_/B1 sky130_fd_sc_hd__buf_2
Xplace395 _3326_/A VGND VGND VPWR VPWR _5648_/A sky130_fd_sc_hd__buf_2
X_6733_ _6967_/CLK _6733_/D VGND VGND VPWR VPWR _6733_/Q sky130_fd_sc_hd__dfxtp_2
X_3945_ _7367_/Q _4488_/A0 _3945_/S VGND VGND VPWR VPWR _7367_/D sky130_fd_sc_hd__mux2_2
X_6664_ _6664_/A VGND VGND VPWR VPWR _6664_/Y sky130_fd_sc_hd__inv_2
XFILLER_31_281 VGND VGND VPWR VPWR sky130_fd_sc_hd__decap_3
X_5615_ _5615_/A _5633_/B VGND VGND VPWR VPWR _7020_/D sky130_fd_sc_hd__or2_2
X_3876_ _6858_/Q _3889_/A2 _3881_/B1 _6898_/Q VGND VGND VPWR VPWR _3876_/X sky130_fd_sc_hd__a22o_2
X_6595_ _6635_/A VGND VGND VPWR VPWR _6595_/Y sky130_fd_sc_hd__inv_2
XFILLER_105_526 VGND VGND VPWR VPWR sky130_fd_sc_hd__decap_3
XFILLER_105_548 VGND VGND VPWR VPWR sky130_fd_sc_hd__decap_3
X_7216_ clkload3/A _7216_/D _6496_/Y VGND VGND VPWR VPWR _7216_/Q sky130_fd_sc_hd__dfrtp_2
X_4428_ _7335_/Q _3945_/S _5229_/C _7143_/Q VGND VGND VPWR VPWR _4428_/X sky130_fd_sc_hd__a22o_2
XFILLER_86_410 VGND VGND VPWR VPWR sky130_fd_sc_hd__decap_3
XFILLER_86_421 VGND VGND VPWR VPWR sky130_fd_sc_hd__decap_3
X_7147_ _7340_/CLK _7147_/D _6427_/Y VGND VGND VPWR VPWR _7147_/Q sky130_fd_sc_hd__dfrtp_2
X_4359_ _4367_/C _4367_/A _4367_/B VGND VGND VPWR VPWR _5071_/B sky130_fd_sc_hd__nand3b_2
XFILLER_100_231 VGND VGND VPWR VPWR sky130_fd_sc_hd__decap_3
XFILLER_100_253 VGND VGND VPWR VPWR sky130_fd_sc_hd__decap_3
XFILLER_104_21 VGND VGND VPWR VPWR sky130_fd_sc_hd__decap_3
XFILLER_58_156 VGND VGND VPWR VPWR sky130_fd_sc_hd__decap_3
XFILLER_86_454 VGND VGND VPWR VPWR sky130_fd_sc_hd__fill_1
X_7078_ _7362_/CLK _7078_/D _6358_/Y VGND VGND VPWR VPWR _7078_/Q sky130_fd_sc_hd__dfrtp_2
XFILLER_100_286 VGND VGND VPWR VPWR sky130_fd_sc_hd__decap_3
XFILLER_104_32 VGND VGND VPWR VPWR sky130_fd_sc_hd__decap_3
XFILLER_46_318 VGND VGND VPWR VPWR sky130_fd_sc_hd__decap_3
XFILLER_74_638 VGND VGND VPWR VPWR sky130_fd_sc_hd__decap_3
XFILLER_104_65 VGND VGND VPWR VPWR sky130_fd_sc_hd__decap_3
XFILLER_27_543 VGND VGND VPWR VPWR sky130_fd_sc_hd__decap_3
XFILLER_27_554 VGND VGND VPWR VPWR sky130_fd_sc_hd__decap_3
XFILLER_39_381 VGND VGND VPWR VPWR sky130_fd_sc_hd__decap_3
XFILLER_64_25 VGND VGND VPWR VPWR sky130_fd_sc_hd__decap_3
XFILLER_64_36 VGND VGND VPWR VPWR sky130_fd_sc_hd__decap_3
XFILLER_104_98 VGND VGND VPWR VPWR sky130_fd_sc_hd__decap_3
XFILLER_42_502 VGND VGND VPWR VPWR sky130_fd_sc_hd__decap_3
XFILLER_42_513 VGND VGND VPWR VPWR sky130_fd_sc_hd__fill_2
XFILLER_54_362 VGND VGND VPWR VPWR sky130_fd_sc_hd__fill_2
XFILLER_54_373 VGND VGND VPWR VPWR sky130_fd_sc_hd__decap_3
XFILLER_64_69 VGND VGND VPWR VPWR sky130_fd_sc_hd__decap_3
XFILLER_14_237 VGND VGND VPWR VPWR sky130_fd_sc_hd__decap_3
XFILLER_81_181 VGND VGND VPWR VPWR sky130_fd_sc_hd__decap_3
XTAP_TAPCELL_ROW_64_1016 VGND VPWR sky130_fd_sc_hd__tapvpwrvgnd_1
XFILLER_14_259 VGND VGND VPWR VPWR sky130_fd_sc_hd__decap_3
XFILLER_80_24 VGND VGND VPWR VPWR sky130_fd_sc_hd__decap_3
Xfanout30 fanout38/X VGND VGND VPWR VPWR _6535_/A sky130_fd_sc_hd__buf_2
XFILLER_80_35 VGND VGND VPWR VPWR sky130_fd_sc_hd__decap_3
Xfanout41 _6547_/A VGND VGND VPWR VPWR _6610_/A sky130_fd_sc_hd__clkdlybuf4s25_1
Xfanout52 _6686_/A VGND VGND VPWR VPWR _6660_/A sky130_fd_sc_hd__buf_2
Xfanout63 fanout72/X VGND VGND VPWR VPWR _6682_/A sky130_fd_sc_hd__clkbuf_2
XTAP_TAPCELL_ROW_40_736 VGND VPWR sky130_fd_sc_hd__tapvpwrvgnd_1
XFILLER_10_421 VGND VGND VPWR VPWR sky130_fd_sc_hd__decap_3
XFILLER_10_432 VGND VGND VPWR VPWR sky130_fd_sc_hd__decap_3
XFILLER_22_281 VGND VGND VPWR VPWR sky130_fd_sc_hd__decap_3
XFILLER_80_68 VGND VGND VPWR VPWR sky130_fd_sc_hd__fill_1
XFILLER_6_414 VGND VGND VPWR VPWR sky130_fd_sc_hd__decap_3
XFILLER_108_342 VGND VGND VPWR VPWR sky130_fd_sc_hd__decap_3
XTAP_TAPCELL_ROW_20_493 VGND VPWR sky130_fd_sc_hd__tapvpwrvgnd_1
XFILLER_89_55 VGND VGND VPWR VPWR sky130_fd_sc_hd__fill_1
XFILLER_89_66 VGND VGND VPWR VPWR sky130_fd_sc_hd__decap_3
XFILLER_89_99 VGND VGND VPWR VPWR sky130_fd_sc_hd__decap_3
XTAP_TAPCELL_ROW_75_1156 VGND VPWR sky130_fd_sc_hd__tapvpwrvgnd_1
XFILLER_96_218 VGND VGND VPWR VPWR sky130_fd_sc_hd__decap_3
XFILLER_104_592 VGND VGND VPWR VPWR sky130_fd_sc_hd__fill_2
XFILLER_77_432 VGND VGND VPWR VPWR sky130_fd_sc_hd__decap_3
XFILLER_89_281 VGND VGND VPWR VPWR sky130_fd_sc_hd__decap_3
XFILLER_89_292 VGND VGND VPWR VPWR sky130_fd_sc_hd__fill_2
XFILLER_1_196 VGND VGND VPWR VPWR sky130_fd_sc_hd__decap_3
XFILLER_49_134 VGND VGND VPWR VPWR sky130_fd_sc_hd__decap_3
XFILLER_77_454 VGND VGND VPWR VPWR sky130_fd_sc_hd__decap_3
XFILLER_38_81 VGND VGND VPWR VPWR sky130_fd_sc_hd__decap_3
XFILLER_49_167 VGND VGND VPWR VPWR sky130_fd_sc_hd__fill_1
XFILLER_49_178 VGND VGND VPWR VPWR sky130_fd_sc_hd__decap_3
XFILLER_77_487 VGND VGND VPWR VPWR sky130_fd_sc_hd__decap_3
XFILLER_92_413 VGND VGND VPWR VPWR sky130_fd_sc_hd__decap_3
XTAP_TAPCELL_ROW_48_825 VGND VPWR sky130_fd_sc_hd__tapvpwrvgnd_1
XFILLER_64_126 VGND VGND VPWR VPWR sky130_fd_sc_hd__decap_3
XPHY_EDGE_ROW_32_Left_149 VGND VGND VPWR VPWR sky130_fd_sc_hd__decap_3
XFILLER_73_671 VGND VGND VPWR VPWR sky130_fd_sc_hd__fill_1
XFILLER_80_619 VGND VGND VPWR VPWR sky130_fd_sc_hd__fill_1
XTAP_TAPCELL_ROW_86_1285 VGND VPWR sky130_fd_sc_hd__tapvpwrvgnd_1
XTAP_TAPCELL_ROW_28_593 VGND VPWR sky130_fd_sc_hd__tapvpwrvgnd_1
XTAP_TAPCELL_ROW_28_582 VGND VPWR sky130_fd_sc_hd__tapvpwrvgnd_1
XFILLER_60_343 VGND VGND VPWR VPWR sky130_fd_sc_hd__decap_3
XFILLER_20_218 VGND VGND VPWR VPWR sky130_fd_sc_hd__decap_3
XFILLER_60_376 VGND VGND VPWR VPWR sky130_fd_sc_hd__decap_3
X_3730_ _6956_/Q _3882_/A2 _3913_/B1 _6950_/Q _3729_/X VGND VGND VPWR VPWR _3730_/X
+ sky130_fd_sc_hd__a221o_2
XFILLER_13_281 VGND VGND VPWR VPWR sky130_fd_sc_hd__decap_3
XFILLER_9_252 VGND VGND VPWR VPWR sky130_fd_sc_hd__decap_3
X_3661_ _3991_/B _3665_/B VGND VGND VPWR VPWR _3661_/X sky130_fd_sc_hd__and2_4
Xclkload11 _6909_/CLK VGND VGND VPWR VPWR clkload11/X sky130_fd_sc_hd__clkbuf_1
Xclkload22 _7359_/CLK VGND VGND VPWR VPWR clkload22/X sky130_fd_sc_hd__clkbuf_1
Xclkload33 _7394_/CLK VGND VGND VPWR VPWR clkload33/X sky130_fd_sc_hd__clkbuf_1
X_6380_ _6540_/A VGND VGND VPWR VPWR _6380_/Y sky130_fd_sc_hd__inv_2
X_5400_ _5400_/A0 _5011_/X _5429_/S VGND VGND VPWR VPWR _7133_/D sky130_fd_sc_hd__mux2_2
X_3592_ _4292_/B _3620_/C _3591_/Y VGND VGND VPWR VPWR _3592_/X sky130_fd_sc_hd__a21o_2
XPHY_EDGE_ROW_41_Left_158 VGND VGND VPWR VPWR sky130_fd_sc_hd__decap_3
XFILLER_114_312 VGND VGND VPWR VPWR sky130_fd_sc_hd__decap_3
X_5331_ _5331_/A0 _5011_/X _5340_/S VGND VGND VPWR VPWR _7165_/D sky130_fd_sc_hd__mux2_2
XFILLER_87_218 VGND VGND VPWR VPWR sky130_fd_sc_hd__decap_3
X_7001_ _7368_/CLK _7001_/D _6281_/Y VGND VGND VPWR VPWR _7001_/Q sky130_fd_sc_hd__dfrtp_2
X_5262_ hold994/X _4978_/X _5262_/S VGND VGND VPWR VPWR _7199_/D sky130_fd_sc_hd__mux2_2
XFILLER_68_410 VGND VGND VPWR VPWR sky130_fd_sc_hd__decap_3
XFILLER_68_421 VGND VGND VPWR VPWR sky130_fd_sc_hd__decap_3
X_4213_ _7292_/Q _4510_/S _4354_/B1 _7356_/Q _4248_/A VGND VGND VPWR VPWR _4213_/X
+ sky130_fd_sc_hd__a221o_2
XFILLER_95_240 VGND VGND VPWR VPWR sky130_fd_sc_hd__decap_3
X_4144_ _7362_/Q _4196_/A2 _3366_/X _7170_/Q VGND VGND VPWR VPWR _4144_/X sky130_fd_sc_hd__a22o_2
XFILLER_18_29 VGND VGND VPWR VPWR sky130_fd_sc_hd__decap_3
XFILLER_28_307 VGND VGND VPWR VPWR sky130_fd_sc_hd__fill_1
XFILLER_28_318 VGND VGND VPWR VPWR sky130_fd_sc_hd__decap_3
XFILLER_83_402 VGND VGND VPWR VPWR sky130_fd_sc_hd__fill_2
XFILLER_95_273 VGND VGND VPWR VPWR sky130_fd_sc_hd__decap_3
XPHY_EDGE_ROW_50_Left_167 VGND VGND VPWR VPWR sky130_fd_sc_hd__decap_3
XFILLER_55_126 VGND VGND VPWR VPWR sky130_fd_sc_hd__decap_3
X_4075_ _7211_/Q _3958_/S _4946_/S _7307_/Q VGND VGND VPWR VPWR _4075_/X sky130_fd_sc_hd__a22o_2
XFILLER_83_479 VGND VGND VPWR VPWR sky130_fd_sc_hd__decap_3
XFILLER_24_513 VGND VGND VPWR VPWR sky130_fd_sc_hd__fill_2
XFILLER_36_395 VGND VGND VPWR VPWR sky130_fd_sc_hd__decap_3
XFILLER_24_568 VGND VGND VPWR VPWR sky130_fd_sc_hd__decap_3
XFILLER_51_332 VGND VGND VPWR VPWR sky130_fd_sc_hd__decap_3
XFILLER_11_207 VGND VGND VPWR VPWR sky130_fd_sc_hd__fill_2
X_6716_ _6966_/CLK _6716_/D VGND VGND VPWR VPWR _6716_/Q sky130_fd_sc_hd__dfxtp_2
X_4977_ _4977_/A _4977_/B VGND VGND VPWR VPWR _6993_/D sky130_fd_sc_hd__nor2_2
Xclkload5 clkload5/A VGND VGND VPWR VPWR clkload5/Y sky130_fd_sc_hd__clkinv_2
X_3928_ hold978/X _5151_/A _3927_/X VGND VGND VPWR VPWR _7375_/D sky130_fd_sc_hd__o21a_2
XFILLER_50_49 VGND VGND VPWR VPWR sky130_fd_sc_hd__decap_3
X_6647_ _6647_/A VGND VGND VPWR VPWR _6647_/Y sky130_fd_sc_hd__inv_2
X_3859_ _6924_/Q _3859_/A2 _3922_/A2 _6788_/Q _3858_/X VGND VGND VPWR VPWR _3859_/X
+ sky130_fd_sc_hd__a221o_2
X_6578_ _6578_/A VGND VGND VPWR VPWR _6578_/Y sky130_fd_sc_hd__inv_2
XFILLER_3_417 VGND VGND VPWR VPWR sky130_fd_sc_hd__decap_3
XFILLER_105_312 VGND VGND VPWR VPWR sky130_fd_sc_hd__decap_3
XFILLER_105_356 VGND VGND VPWR VPWR sky130_fd_sc_hd__fill_2
XFILLER_59_36 VGND VGND VPWR VPWR sky130_fd_sc_hd__decap_3
XFILLER_99_590 VGND VGND VPWR VPWR sky130_fd_sc_hd__fill_1
XFILLER_115_42 VGND VGND VPWR VPWR sky130_fd_sc_hd__decap_3
XFILLER_59_432 VGND VGND VPWR VPWR sky130_fd_sc_hd__decap_3
XFILLER_59_465 VGND VGND VPWR VPWR sky130_fd_sc_hd__decap_3
XFILLER_101_584 VGND VGND VPWR VPWR sky130_fd_sc_hd__decap_3
XFILLER_19_329 VGND VGND VPWR VPWR sky130_fd_sc_hd__decap_3
XFILLER_59_498 VGND VGND VPWR VPWR sky130_fd_sc_hd__decap_3
XFILLER_75_24 VGND VGND VPWR VPWR sky130_fd_sc_hd__decap_3
XFILLER_86_251 VGND VGND VPWR VPWR sky130_fd_sc_hd__fill_1
XFILLER_86_273 VGND VGND VPWR VPWR sky130_fd_sc_hd__decap_3
XTAP_TAPCELL_ROW_70_1097 VGND VPWR sky130_fd_sc_hd__tapvpwrvgnd_1
XTAP_TAPCELL_ROW_70_1086 VGND VPWR sky130_fd_sc_hd__tapvpwrvgnd_1
XFILLER_74_446 VGND VGND VPWR VPWR sky130_fd_sc_hd__decap_3
XFILLER_75_57 VGND VGND VPWR VPWR sky130_fd_sc_hd__decap_3
XFILLER_27_340 VGND VGND VPWR VPWR sky130_fd_sc_hd__decap_3
XFILLER_46_159 VGND VGND VPWR VPWR sky130_fd_sc_hd__fill_1
XFILLER_55_671 VGND VGND VPWR VPWR sky130_fd_sc_hd__fill_1
XFILLER_27_373 VGND VGND VPWR VPWR sky130_fd_sc_hd__decap_3
XFILLER_70_663 VGND VGND VPWR VPWR sky130_fd_sc_hd__decap_3
XFILLER_91_34 VGND VGND VPWR VPWR sky130_fd_sc_hd__decap_3
XFILLER_24_50 VGND VGND VPWR VPWR sky130_fd_sc_hd__decap_3
XFILLER_42_365 VGND VGND VPWR VPWR sky130_fd_sc_hd__decap_3
XFILLER_42_376 VGND VGND VPWR VPWR sky130_fd_sc_hd__decap_3
XFILLER_91_78 VGND VGND VPWR VPWR sky130_fd_sc_hd__fill_1
XTAP_TAPCELL_ROW_53_883 VGND VPWR sky130_fd_sc_hd__tapvpwrvgnd_1
XTAP_TAPCELL_ROW_25_552 VGND VPWR sky130_fd_sc_hd__tapvpwrvgnd_1
XFILLER_24_72 VGND VGND VPWR VPWR sky130_fd_sc_hd__decap_3
XFILLER_10_284 VGND VGND VPWR VPWR sky130_fd_sc_hd__decap_3
XFILLER_108_161 VGND VGND VPWR VPWR sky130_fd_sc_hd__decap_3
XFILLER_109_673 VGND VGND VPWR VPWR sky130_fd_sc_hd__decap_3
XFILLER_6_266 VGND VGND VPWR VPWR sky130_fd_sc_hd__decap_3
XFILLER_108_194 VGND VGND VPWR VPWR sky130_fd_sc_hd__fill_2
XFILLER_6_288 VGND VGND VPWR VPWR sky130_fd_sc_hd__decap_3
XFILLER_97_538 VGND VGND VPWR VPWR sky130_fd_sc_hd__decap_3
XFILLER_27_6 VGND VGND VPWR VPWR sky130_fd_sc_hd__decap_3
XFILLER_77_240 VGND VGND VPWR VPWR sky130_fd_sc_hd__decap_3
XFILLER_65_402 VGND VGND VPWR VPWR sky130_fd_sc_hd__decap_3
XTAP_TAPCELL_ROW_88_1303 VGND VPWR sky130_fd_sc_hd__tapvpwrvgnd_1
XFILLER_37_137 VGND VGND VPWR VPWR sky130_fd_sc_hd__decap_3
XFILLER_65_435 VGND VGND VPWR VPWR sky130_fd_sc_hd__decap_3
XFILLER_77_295 VGND VGND VPWR VPWR sky130_fd_sc_hd__decap_3
XFILLER_92_232 VGND VGND VPWR VPWR sky130_fd_sc_hd__decap_3
XFILLER_1_87 VGND VGND VPWR VPWR sky130_fd_sc_hd__decap_3
XFILLER_65_479 VGND VGND VPWR VPWR sky130_fd_sc_hd__decap_3
XFILLER_18_384 VGND VGND VPWR VPWR sky130_fd_sc_hd__decap_3
XFILLER_33_321 VGND VGND VPWR VPWR sky130_fd_sc_hd__decap_3
XFILLER_46_682 VGND VGND VPWR VPWR sky130_fd_sc_hd__fill_1
XFILLER_52_118 VGND VGND VPWR VPWR sky130_fd_sc_hd__decap_3
XFILLER_73_490 VGND VGND VPWR VPWR sky130_fd_sc_hd__decap_3
XFILLER_80_427 VGND VGND VPWR VPWR sky130_fd_sc_hd__decap_3
XFILLER_92_298 VGND VGND VPWR VPWR sky130_fd_sc_hd__fill_1
XFILLER_33_343 VGND VGND VPWR VPWR sky130_fd_sc_hd__decap_3
X_4831_ _4969_/B _4827_/X _4828_/X _4830_/X VGND VGND VPWR VPWR _5657_/A sky130_fd_sc_hd__a211o_2
XFILLER_33_376 VGND VGND VPWR VPWR sky130_fd_sc_hd__decap_3
XFILLER_60_173 VGND VGND VPWR VPWR sky130_fd_sc_hd__decap_3
X_4762_ _4762_/A _4762_/B VGND VGND VPWR VPWR _4762_/Y sky130_fd_sc_hd__nor2_2
X_6501_ _6599_/A VGND VGND VPWR VPWR _6501_/Y sky130_fd_sc_hd__inv_2
X_4693_ _7007_/Q _4750_/B VGND VGND VPWR VPWR _4728_/A sky130_fd_sc_hd__nand2_2
X_3713_ _3733_/C VGND VGND VPWR VPWR _3746_/C sky130_fd_sc_hd__inv_4
XTAP_TAPCELL_ROW_99_1443 VGND VPWR sky130_fd_sc_hd__tapvpwrvgnd_1
X_6432_ _6637_/A VGND VGND VPWR VPWR _6432_/Y sky130_fd_sc_hd__inv_2
X_3644_ _3629_/Y _3642_/X _3818_/A2 VGND VGND VPWR VPWR _4664_/B sky130_fd_sc_hd__o21a_2
X_6363_ _6366_/A VGND VGND VPWR VPWR _6363_/Y sky130_fd_sc_hd__inv_2
X_3575_ _7156_/Q _4348_/A2 _4348_/B1 _7124_/Q _3574_/X VGND VGND VPWR VPWR _3575_/X
+ sky130_fd_sc_hd__a221o_2
XFILLER_115_665 VGND VGND VPWR VPWR sky130_fd_sc_hd__fill_1
XFILLER_88_516 VGND VGND VPWR VPWR sky130_fd_sc_hd__decap_3
X_6294_ _6532_/A VGND VGND VPWR VPWR _6294_/Y sky130_fd_sc_hd__inv_2
XFILLER_102_315 VGND VGND VPWR VPWR sky130_fd_sc_hd__decap_3
XFILLER_29_17 VGND VGND VPWR VPWR sky130_fd_sc_hd__decap_3
X_5245_ _5245_/A0 _4836_/X _5245_/S VGND VGND VPWR VPWR _7207_/D sky130_fd_sc_hd__mux2_2
XFILLER_102_348 VGND VGND VPWR VPWR sky130_fd_sc_hd__decap_3
XFILLER_56_402 VGND VGND VPWR VPWR sky130_fd_sc_hd__decap_3
XFILLER_68_273 VGND VGND VPWR VPWR sky130_fd_sc_hd__decap_3
XFILLER_96_560 VGND VGND VPWR VPWR sky130_fd_sc_hd__decap_3
XFILLER_110_392 VGND VGND VPWR VPWR sky130_fd_sc_hd__decap_3
XFILLER_28_137 VGND VGND VPWR VPWR sky130_fd_sc_hd__decap_3
XFILLER_56_424 VGND VGND VPWR VPWR sky130_fd_sc_hd__decap_3
XFILLER_28_159 VGND VGND VPWR VPWR sky130_fd_sc_hd__decap_3
XFILLER_83_243 VGND VGND VPWR VPWR sky130_fd_sc_hd__decap_3
X_4058_ _7244_/Q _4430_/A2 _4430_/B1 _7180_/Q _4057_/X VGND VGND VPWR VPWR _4058_/X
+ sky130_fd_sc_hd__a221o_2
XTAP_TAPCELL_ROW_108_1550 VGND VPWR sky130_fd_sc_hd__tapvpwrvgnd_1
XFILLER_36_170 VGND VGND VPWR VPWR sky130_fd_sc_hd__decap_3
XFILLER_71_438 VGND VGND VPWR VPWR sky130_fd_sc_hd__decap_3
XFILLER_83_287 VGND VGND VPWR VPWR sky130_fd_sc_hd__decap_3
XFILLER_24_321 VGND VGND VPWR VPWR sky130_fd_sc_hd__fill_1
XFILLER_101_55 VGND VGND VPWR VPWR sky130_fd_sc_hd__fill_1
XFILLER_101_66 VGND VGND VPWR VPWR sky130_fd_sc_hd__decap_3
XFILLER_24_365 VGND VGND VPWR VPWR sky130_fd_sc_hd__decap_3
XFILLER_51_151 VGND VGND VPWR VPWR sky130_fd_sc_hd__decap_3
XFILLER_61_15 VGND VGND VPWR VPWR sky130_fd_sc_hd__decap_3
XTAP_TAPCELL_ROW_22_511 VGND VPWR sky130_fd_sc_hd__tapvpwrvgnd_1
XTAP_TAPCELL_ROW_50_853 VGND VPWR sky130_fd_sc_hd__tapvpwrvgnd_1
XFILLER_106_643 VGND VGND VPWR VPWR sky130_fd_sc_hd__fill_1
XFILLER_106_654 VGND VGND VPWR VPWR sky130_fd_sc_hd__decap_3
XFILLER_79_516 VGND VGND VPWR VPWR sky130_fd_sc_hd__decap_3
XTAP_TAPCELL_ROW_72_1115 VGND VPWR sky130_fd_sc_hd__tapvpwrvgnd_1
XFILLER_105_175 VGND VGND VPWR VPWR sky130_fd_sc_hd__decap_3
XFILLER_10_85 VGND VGND VPWR VPWR sky130_fd_sc_hd__fill_2
XFILLER_59_240 VGND VGND VPWR VPWR sky130_fd_sc_hd__decap_3
XFILLER_86_23 VGND VGND VPWR VPWR sky130_fd_sc_hd__decap_3
XFILLER_86_56 VGND VGND VPWR VPWR sky130_fd_sc_hd__decap_3
XFILLER_47_402 VGND VGND VPWR VPWR sky130_fd_sc_hd__decap_3
XFILLER_87_582 VGND VGND VPWR VPWR sky130_fd_sc_hd__decap_3
XFILLER_101_381 VGND VGND VPWR VPWR sky130_fd_sc_hd__decap_3
XFILLER_19_83 VGND VGND VPWR VPWR sky130_fd_sc_hd__decap_3
XFILLER_47_446 VGND VGND VPWR VPWR sky130_fd_sc_hd__fill_2
XFILLER_59_284 VGND VGND VPWR VPWR sky130_fd_sc_hd__decap_3
XFILLER_74_221 VGND VGND VPWR VPWR sky130_fd_sc_hd__decap_3
XTAP_TAPCELL_ROW_58_942 VGND VPWR sky130_fd_sc_hd__tapvpwrvgnd_1
XTAP_TAPCELL_ROW_58_953 VGND VPWR sky130_fd_sc_hd__tapvpwrvgnd_1
XFILLER_15_310 VGND VGND VPWR VPWR sky130_fd_sc_hd__decap_3
XFILLER_34_129 VGND VGND VPWR VPWR sky130_fd_sc_hd__decap_3
XFILLER_62_427 VGND VGND VPWR VPWR sky130_fd_sc_hd__decap_3
XFILLER_74_287 VGND VGND VPWR VPWR sky130_fd_sc_hd__fill_1
XTAP_TAPCELL_ROW_2_280 VGND VPWR sky130_fd_sc_hd__tapvpwrvgnd_1
XFILLER_15_343 VGND VGND VPWR VPWR sky130_fd_sc_hd__decap_3
XFILLER_27_181 VGND VGND VPWR VPWR sky130_fd_sc_hd__decap_3
XFILLER_35_60 VGND VGND VPWR VPWR sky130_fd_sc_hd__decap_3
XTAP_TAPCELL_ROW_83_1244 VGND VPWR sky130_fd_sc_hd__tapvpwrvgnd_1
XPHY_EDGE_ROW_106_Left_223 VGND VGND VPWR VPWR sky130_fd_sc_hd__decap_3
XFILLER_35_93 VGND VGND VPWR VPWR sky130_fd_sc_hd__decap_3
XFILLER_70_471 VGND VGND VPWR VPWR sky130_fd_sc_hd__decap_3
XFILLER_30_368 VGND VGND VPWR VPWR sky130_fd_sc_hd__decap_3
XFILLER_51_81 VGND VGND VPWR VPWR sky130_fd_sc_hd__decap_3
XFILLER_51_92 VGND VGND VPWR VPWR sky130_fd_sc_hd__decap_3
X_3360_ _3365_/A _3362_/A _3371_/A VGND VGND VPWR VPWR _3386_/B sky130_fd_sc_hd__mux2_2
XTAP_TAPCELL_ROW_94_1384 VGND VPWR sky130_fd_sc_hd__tapvpwrvgnd_1
XPHY_EDGE_ROW_115_Left_232 VGND VGND VPWR VPWR sky130_fd_sc_hd__decap_3
XFILLER_112_624 VGND VGND VPWR VPWR sky130_fd_sc_hd__decap_3
XFILLER_97_302 VGND VGND VPWR VPWR sky130_fd_sc_hd__decap_3
XFILLER_97_357 VGND VGND VPWR VPWR sky130_fd_sc_hd__decap_3
X_5030_ _6989_/Q _5044_/A VGND VGND VPWR VPWR _6989_/D sky130_fd_sc_hd__xor2_2
XFILLER_25_3 VGND VGND VPWR VPWR sky130_fd_sc_hd__decap_3
XFILLER_97_379 VGND VGND VPWR VPWR sky130_fd_sc_hd__decap_3
Xhold1209 _7154_/Q VGND VGND VPWR VPWR _5354_/A0 sky130_fd_sc_hd__dlygate4sd3_1
XFILLER_38_446 VGND VGND VPWR VPWR sky130_fd_sc_hd__decap_3
XFILLER_53_405 VGND VGND VPWR VPWR sky130_fd_sc_hd__decap_3
XFILLER_65_254 VGND VGND VPWR VPWR sky130_fd_sc_hd__decap_3
X_6981_ _7364_/CLK _6981_/D _6261_/Y VGND VGND VPWR VPWR _6981_/Q sky130_fd_sc_hd__dfrtp_2
XFILLER_53_438 VGND VGND VPWR VPWR sky130_fd_sc_hd__decap_3
XFILLER_65_298 VGND VGND VPWR VPWR sky130_fd_sc_hd__decap_3
XFILLER_80_213 VGND VGND VPWR VPWR sky130_fd_sc_hd__decap_3
XTAP_TAPCELL_ROW_0_239 VGND VPWR sky130_fd_sc_hd__tapvpwrvgnd_1
XFILLER_18_181 VGND VGND VPWR VPWR sky130_fd_sc_hd__decap_3
XFILLER_53_449 VGND VGND VPWR VPWR sky130_fd_sc_hd__fill_1
XFILLER_80_246 VGND VGND VPWR VPWR sky130_fd_sc_hd__decap_3
Xclkbuf_leaf_45_clk clkbuf_3_0__f_clk/X VGND VGND VPWR VPWR clkload5/A sky130_fd_sc_hd__clkbuf_16
XFILLER_80_268 VGND VGND VPWR VPWR sky130_fd_sc_hd__decap_3
XFILLER_21_313 VGND VGND VPWR VPWR sky130_fd_sc_hd__decap_3
XFILLER_21_335 VGND VGND VPWR VPWR sky130_fd_sc_hd__fill_1
XFILLER_21_346 VGND VGND VPWR VPWR sky130_fd_sc_hd__decap_3
XFILLER_33_184 VGND VGND VPWR VPWR sky130_fd_sc_hd__decap_3
X_4814_ _4814_/A _4814_/B VGND VGND VPWR VPWR _4814_/Y sky130_fd_sc_hd__nor2_2
XFILLER_21_368 VGND VGND VPWR VPWR sky130_fd_sc_hd__decap_3
X_4745_ _4745_/A VGND VGND VPWR VPWR _4745_/Y sky130_fd_sc_hd__inv_2
XTAP_TAPCELL_ROW_103_1491 VGND VPWR sky130_fd_sc_hd__tapvpwrvgnd_1
XFILLER_107_407 VGND VGND VPWR VPWR sky130_fd_sc_hd__decap_3
XFILLER_107_429 VGND VGND VPWR VPWR sky130_fd_sc_hd__decap_3
X_4676_ _5648_/A _5067_/B _6985_/Q _6986_/Q _6987_/Q VGND VGND VPWR VPWR _5045_/B
+ sky130_fd_sc_hd__o2111a_2
X_7395_ _7403_/CLK _7395_/D _6675_/Y VGND VGND VPWR VPWR _7395_/Q sky130_fd_sc_hd__dfrtp_2
X_6415_ _6548_/A VGND VGND VPWR VPWR _6415_/Y sky130_fd_sc_hd__inv_2
X_3627_ _3746_/A _3746_/B _3733_/C VGND VGND VPWR VPWR _5660_/A sky130_fd_sc_hd__and3_2
X_6346_ _6540_/A VGND VGND VPWR VPWR _6346_/Y sky130_fd_sc_hd__inv_2
X_3558_ _7061_/Q _3577_/B VGND VGND VPWR VPWR _3558_/X sky130_fd_sc_hd__or2_2
XFILLER_0_206 VGND VGND VPWR VPWR sky130_fd_sc_hd__decap_3
XFILLER_0_228 VGND VGND VPWR VPWR sky130_fd_sc_hd__decap_3
XFILLER_88_324 VGND VGND VPWR VPWR sky130_fd_sc_hd__decap_3
XFILLER_0_239 VGND VGND VPWR VPWR sky130_fd_sc_hd__decap_3
XFILLER_102_112 VGND VGND VPWR VPWR sky130_fd_sc_hd__decap_3
XFILLER_88_368 VGND VGND VPWR VPWR sky130_fd_sc_hd__decap_3
X_6277_ _6652_/A VGND VGND VPWR VPWR _6277_/Y sky130_fd_sc_hd__inv_2
X_3489_ _7311_/Q _3977_/S _4332_/B1 _7343_/Q _3488_/X VGND VGND VPWR VPWR _3489_/X
+ sky130_fd_sc_hd__a221o_2
XFILLER_69_571 VGND VGND VPWR VPWR sky130_fd_sc_hd__decap_3
XFILLER_76_519 VGND VGND VPWR VPWR sky130_fd_sc_hd__decap_3
X_5228_ _5238_/B VGND VGND VPWR VPWR _5229_/B sky130_fd_sc_hd__inv_2
XFILLER_56_221 VGND VGND VPWR VPWR sky130_fd_sc_hd__decap_3
XFILLER_56_26 VGND VGND VPWR VPWR sky130_fd_sc_hd__fill_2
X_5159_ _5159_/A0 _4470_/X _5159_/S VGND VGND VPWR VPWR _7247_/D sky130_fd_sc_hd__mux2_2
XFILLER_29_479 VGND VGND VPWR VPWR sky130_fd_sc_hd__decap_3
XFILLER_56_265 VGND VGND VPWR VPWR sky130_fd_sc_hd__decap_3
XFILLER_56_59 VGND VGND VPWR VPWR sky130_fd_sc_hd__decap_3
XFILLER_112_21 VGND VGND VPWR VPWR sky130_fd_sc_hd__decap_3
XFILLER_112_43 VGND VGND VPWR VPWR sky130_fd_sc_hd__decap_3
XFILLER_44_427 VGND VGND VPWR VPWR sky130_fd_sc_hd__decap_3
XFILLER_56_298 VGND VGND VPWR VPWR sky130_fd_sc_hd__decap_3
XFILLER_71_202 VGND VGND VPWR VPWR sky130_fd_sc_hd__decap_3
XFILLER_84_585 VGND VGND VPWR VPWR sky130_fd_sc_hd__decap_3
XTAP_TAPCELL_ROW_55_912 VGND VPWR sky130_fd_sc_hd__tapvpwrvgnd_1
XFILLER_112_65 VGND VGND VPWR VPWR sky130_fd_sc_hd__decap_3
XFILLER_71_246 VGND VGND VPWR VPWR sky130_fd_sc_hd__decap_3
Xclkbuf_leaf_36_clk clkbuf_3_0__f_clk/X VGND VGND VPWR VPWR clkload1/A sky130_fd_sc_hd__clkbuf_16
XFILLER_24_162 VGND VGND VPWR VPWR sky130_fd_sc_hd__decap_3
XFILLER_52_471 VGND VGND VPWR VPWR sky130_fd_sc_hd__decap_3
XFILLER_71_279 VGND VGND VPWR VPWR sky130_fd_sc_hd__fill_1
XFILLER_72_47 VGND VGND VPWR VPWR sky130_fd_sc_hd__decap_3
XFILLER_12_324 VGND VGND VPWR VPWR sky130_fd_sc_hd__decap_3
XFILLER_24_195 VGND VGND VPWR VPWR sky130_fd_sc_hd__fill_1
XFILLER_12_368 VGND VGND VPWR VPWR sky130_fd_sc_hd__decap_3
XFILLER_20_390 VGND VGND VPWR VPWR sky130_fd_sc_hd__decap_3
XFILLER_21_40 VGND VGND VPWR VPWR sky130_fd_sc_hd__decap_3
XFILLER_106_451 VGND VGND VPWR VPWR sky130_fd_sc_hd__decap_3
XFILLER_21_95 VGND VGND VPWR VPWR sky130_fd_sc_hd__decap_3
XFILLER_97_33 VGND VGND VPWR VPWR sky130_fd_sc_hd__decap_3
XFILLER_97_77 VGND VGND VPWR VPWR sky130_fd_sc_hd__decap_3
XFILLER_67_508 VGND VGND VPWR VPWR sky130_fd_sc_hd__decap_3
XFILLER_94_305 VGND VGND VPWR VPWR sky130_fd_sc_hd__decap_3
XFILLER_102_690 VGND VGND VPWR VPWR sky130_fd_sc_hd__fill_2
XFILLER_47_221 VGND VGND VPWR VPWR sky130_fd_sc_hd__decap_3
XFILLER_94_327 VGND VGND VPWR VPWR sky130_fd_sc_hd__decap_3
XFILLER_47_243 VGND VGND VPWR VPWR sky130_fd_sc_hd__decap_3
XFILLER_75_552 VGND VGND VPWR VPWR sky130_fd_sc_hd__decap_3
XFILLER_46_70 VGND VGND VPWR VPWR sky130_fd_sc_hd__decap_3
XFILLER_62_213 VGND VGND VPWR VPWR sky130_fd_sc_hd__decap_3
XFILLER_75_585 VGND VGND VPWR VPWR sky130_fd_sc_hd__decap_3
XFILLER_90_533 VGND VGND VPWR VPWR sky130_fd_sc_hd__decap_3
XFILLER_62_246 VGND VGND VPWR VPWR sky130_fd_sc_hd__decap_3
Xclkbuf_leaf_27_clk clkbuf_3_3__f_clk/X VGND VGND VPWR VPWR _6968_/CLK sky130_fd_sc_hd__clkbuf_16
XFILLER_15_162 VGND VGND VPWR VPWR sky130_fd_sc_hd__decap_3
XFILLER_50_419 VGND VGND VPWR VPWR sky130_fd_sc_hd__fill_1
XFILLER_15_184 VGND VGND VPWR VPWR sky130_fd_sc_hd__decap_3
XFILLER_30_132 VGND VGND VPWR VPWR sky130_fd_sc_hd__decap_3
XFILLER_62_91 VGND VGND VPWR VPWR sky130_fd_sc_hd__decap_3
XFILLER_30_165 VGND VGND VPWR VPWR sky130_fd_sc_hd__decap_3
X_4530_ _4530_/A0 _7282_/Q _4530_/S VGND VGND VPWR VPWR _7314_/D sky130_fd_sc_hd__mux2_2
XTAP_TAPCELL_ROW_96_1402 VGND VPWR sky130_fd_sc_hd__tapvpwrvgnd_1
XFILLER_116_237 VGND VGND VPWR VPWR sky130_fd_sc_hd__decap_3
XFILLER_7_361 VGND VGND VPWR VPWR sky130_fd_sc_hd__decap_3
XFILLER_116_259 VGND VGND VPWR VPWR sky130_fd_sc_hd__decap_3
X_7180_ _7340_/CLK _7180_/D _6460_/Y VGND VGND VPWR VPWR _7180_/Q sky130_fd_sc_hd__dfrtp_2
X_3412_ _7187_/Q _3994_/S _4332_/B1 _7379_/Q VGND VGND VPWR VPWR _3412_/X sky130_fd_sc_hd__a22o_2
XFILLER_112_410 VGND VGND VPWR VPWR sky130_fd_sc_hd__decap_3
X_4392_ _7369_/Q _4435_/B1 _4434_/B1 _7145_/Q _4391_/X VGND VGND VPWR VPWR _4392_/X
+ sky130_fd_sc_hd__a221o_2
XFILLER_112_421 VGND VGND VPWR VPWR sky130_fd_sc_hd__decap_3
XTAP_TAPCELL_ROW_5_309 VGND VPWR sky130_fd_sc_hd__tapvpwrvgnd_1
XFILLER_58_519 VGND VGND VPWR VPWR sky130_fd_sc_hd__decap_3
XFILLER_85_316 VGND VGND VPWR VPWR sky130_fd_sc_hd__decap_3
Xhold1006 _7263_/Q VGND VGND VPWR VPWR _4979_/A0 sky130_fd_sc_hd__dlygate4sd3_1
Xhold1017 _7034_/Q VGND VGND VPWR VPWR _5587_/A sky130_fd_sc_hd__dlygate4sd3_1
Xhold1028 _7268_/Q VGND VGND VPWR VPWR _4901_/A0 sky130_fd_sc_hd__dlygate4sd3_1
Xhold1039 _7054_/Q VGND VGND VPWR VPWR _5561_/A1 sky130_fd_sc_hd__dlygate4sd3_1
XFILLER_26_18 VGND VGND VPWR VPWR sky130_fd_sc_hd__decap_3
XFILLER_26_29 VGND VGND VPWR VPWR sky130_fd_sc_hd__decap_3
XFILLER_26_416 VGND VGND VPWR VPWR sky130_fd_sc_hd__decap_3
XFILLER_38_265 VGND VGND VPWR VPWR sky130_fd_sc_hd__decap_3
XFILLER_53_213 VGND VGND VPWR VPWR sky130_fd_sc_hd__decap_3
XFILLER_66_596 VGND VGND VPWR VPWR sky130_fd_sc_hd__decap_3
XFILLER_81_500 VGND VGND VPWR VPWR sky130_fd_sc_hd__decap_3
XFILLER_93_382 VGND VGND VPWR VPWR sky130_fd_sc_hd__decap_3
XFILLER_81_544 VGND VGND VPWR VPWR sky130_fd_sc_hd__decap_3
XFILLER_93_393 VGND VGND VPWR VPWR sky130_fd_sc_hd__decap_3
Xclkbuf_leaf_18_clk clkbuf_3_6__f_clk/X VGND VGND VPWR VPWR _7404_/CLK sky130_fd_sc_hd__clkbuf_16
X_6964_ _6972_/CLK _6964_/D VGND VGND VPWR VPWR _6964_/Q sky130_fd_sc_hd__dfxtp_2
XPHY_EDGE_ROW_5_Right_5 VGND VGND VPWR VPWR sky130_fd_sc_hd__decap_3
XFILLER_41_419 VGND VGND VPWR VPWR sky130_fd_sc_hd__decap_3
XFILLER_81_577 VGND VGND VPWR VPWR sky130_fd_sc_hd__decap_3
XFILLER_81_588 VGND VGND VPWR VPWR sky130_fd_sc_hd__decap_3
X_6895_ _6966_/CLK _6895_/D VGND VGND VPWR VPWR _6895_/Q sky130_fd_sc_hd__dfxtp_2
XFILLER_21_110 VGND VGND VPWR VPWR sky130_fd_sc_hd__fill_2
XFILLER_21_154 VGND VGND VPWR VPWR sky130_fd_sc_hd__decap_3
XFILLER_61_290 VGND VGND VPWR VPWR sky130_fd_sc_hd__decap_3
XFILLER_21_187 VGND VGND VPWR VPWR sky130_fd_sc_hd__decap_3
XTAP_TAPCELL_ROW_60_970 VGND VPWR sky130_fd_sc_hd__tapvpwrvgnd_1
X_4728_ _4728_/A _4728_/B VGND VGND VPWR VPWR _4729_/B sky130_fd_sc_hd__nand2_2
XFILLER_107_237 VGND VGND VPWR VPWR sky130_fd_sc_hd__decap_3
X_4659_ _4814_/A _4457_/X _4658_/Y _4852_/A _4040_/Y VGND VGND VPWR VPWR _4659_/X
+ sky130_fd_sc_hd__o2111a_2
XTAP_TAPCELL_ROW_116_1660 VGND VPWR sky130_fd_sc_hd__tapvpwrvgnd_1
XFILLER_107_32 VGND VGND VPWR VPWR sky130_fd_sc_hd__decap_3
X_7378_ _7384_/CLK _7378_/D _6658_/Y VGND VGND VPWR VPWR _7378_/Q sky130_fd_sc_hd__dfrtp_2
Xhold840 _6916_/Q VGND VGND VPWR VPWR _6916_/D sky130_fd_sc_hd__dlygate4sd3_1
Xhold851 _7076_/Q VGND VGND VPWR VPWR _7076_/D sky130_fd_sc_hd__dlygate4sd3_1
Xhold862 _7118_/Q VGND VGND VPWR VPWR _7118_/D sky130_fd_sc_hd__dlygate4sd3_1
Xhold873 _7114_/Q VGND VGND VPWR VPWR _7114_/D sky130_fd_sc_hd__dlygate4sd3_1
Xmax_cap581 _6288_/A VGND VGND VPWR VPWR _6287_/A sky130_fd_sc_hd__buf_2
XFILLER_103_443 VGND VGND VPWR VPWR sky130_fd_sc_hd__decap_3
XFILLER_107_54 VGND VGND VPWR VPWR sky130_fd_sc_hd__fill_2
XFILLER_115_281 VGND VGND VPWR VPWR sky130_fd_sc_hd__fill_1
XFILLER_1_537 VGND VGND VPWR VPWR sky130_fd_sc_hd__fill_1
XFILLER_88_132 VGND VGND VPWR VPWR sky130_fd_sc_hd__decap_3
XFILLER_89_644 VGND VGND VPWR VPWR sky130_fd_sc_hd__decap_3
Xhold884 _7092_/Q VGND VGND VPWR VPWR _7092_/D sky130_fd_sc_hd__dlygate4sd3_1
Xhold895 _7083_/Q VGND VGND VPWR VPWR _7083_/D sky130_fd_sc_hd__dlygate4sd3_1
X_6329_ _6616_/A VGND VGND VPWR VPWR _6329_/Y sky130_fd_sc_hd__inv_2
XFILLER_67_47 VGND VGND VPWR VPWR sky130_fd_sc_hd__fill_1
XFILLER_76_305 VGND VGND VPWR VPWR sky130_fd_sc_hd__decap_3
XFILLER_88_165 VGND VGND VPWR VPWR sky130_fd_sc_hd__decap_3
XFILLER_89_688 VGND VGND VPWR VPWR sky130_fd_sc_hd__decap_3
XFILLER_69_390 VGND VGND VPWR VPWR sky130_fd_sc_hd__fill_2
XFILLER_29_254 VGND VGND VPWR VPWR sky130_fd_sc_hd__decap_3
XFILLER_72_511 VGND VGND VPWR VPWR sky130_fd_sc_hd__decap_3
XFILLER_83_35 VGND VGND VPWR VPWR sky130_fd_sc_hd__fill_1
XFILLER_84_371 VGND VGND VPWR VPWR sky130_fd_sc_hd__decap_3
XFILLER_17_449 VGND VGND VPWR VPWR sky130_fd_sc_hd__decap_3
XFILLER_44_224 VGND VGND VPWR VPWR sky130_fd_sc_hd__fill_1
XFILLER_72_533 VGND VGND VPWR VPWR sky130_fd_sc_hd__fill_1
XFILLER_83_46 VGND VGND VPWR VPWR sky130_fd_sc_hd__decap_3
XFILLER_83_57 VGND VGND VPWR VPWR sky130_fd_sc_hd__decap_3
XTAP_TAPCELL_ROW_67_1058 VGND VPWR sky130_fd_sc_hd__tapvpwrvgnd_1
XFILLER_16_51 VGND VGND VPWR VPWR sky130_fd_sc_hd__decap_3
XFILLER_32_419 VGND VGND VPWR VPWR sky130_fd_sc_hd__fill_1
XFILLER_44_268 VGND VGND VPWR VPWR sky130_fd_sc_hd__decap_3
XFILLER_72_566 VGND VGND VPWR VPWR sky130_fd_sc_hd__decap_3
XFILLER_72_599 VGND VGND VPWR VPWR sky130_fd_sc_hd__fill_2
XFILLER_12_110 VGND VGND VPWR VPWR sky130_fd_sc_hd__decap_3
XTAP_TAPCELL_ROW_80_1214 VGND VPWR sky130_fd_sc_hd__tapvpwrvgnd_1
XFILLER_40_430 VGND VGND VPWR VPWR sky130_fd_sc_hd__decap_3
XFILLER_8_103 VGND VGND VPWR VPWR sky130_fd_sc_hd__decap_3
XTAP_TAPCELL_ROW_30_609 VGND VPWR sky130_fd_sc_hd__tapvpwrvgnd_1
XFILLER_40_474 VGND VGND VPWR VPWR sky130_fd_sc_hd__fill_2
XFILLER_8_147 VGND VGND VPWR VPWR sky130_fd_sc_hd__decap_3
XTAP_TAPCELL_ROW_10_377 VGND VPWR sky130_fd_sc_hd__tapvpwrvgnd_1
XTAP_TAPCELL_ROW_10_366 VGND VPWR sky130_fd_sc_hd__tapvpwrvgnd_1
XFILLER_4_342 VGND VGND VPWR VPWR sky130_fd_sc_hd__decap_3
XTAP_TAPCELL_ROW_78_1187 VGND VPWR sky130_fd_sc_hd__tapvpwrvgnd_1
XFILLER_113_207 VGND VGND VPWR VPWR sky130_fd_sc_hd__decap_3
XFILLER_4_397 VGND VGND VPWR VPWR sky130_fd_sc_hd__decap_3
XTAP_TAPCELL_ROW_91_1343 VGND VPWR sky130_fd_sc_hd__tapvpwrvgnd_1
XFILLER_79_143 VGND VGND VPWR VPWR sky130_fd_sc_hd__decap_3
XFILLER_95_603 VGND VGND VPWR VPWR sky130_fd_sc_hd__decap_3
XFILLER_67_349 VGND VGND VPWR VPWR sky130_fd_sc_hd__decap_3
XFILLER_95_636 VGND VGND VPWR VPWR sky130_fd_sc_hd__decap_3
XFILLER_48_552 VGND VGND VPWR VPWR sky130_fd_sc_hd__fill_2
XTAP_TAPCELL_ROW_38_709 VGND VPWR sky130_fd_sc_hd__tapvpwrvgnd_1
XFILLER_35_213 VGND VGND VPWR VPWR sky130_fd_sc_hd__decap_3
XFILLER_48_585 VGND VGND VPWR VPWR sky130_fd_sc_hd__decap_3
XFILLER_63_522 VGND VGND VPWR VPWR sky130_fd_sc_hd__decap_3
XFILLER_63_555 VGND VGND VPWR VPWR sky130_fd_sc_hd__decap_3
XFILLER_75_393 VGND VGND VPWR VPWR sky130_fd_sc_hd__decap_3
XFILLER_90_330 VGND VGND VPWR VPWR sky130_fd_sc_hd__decap_3
XFILLER_23_408 VGND VGND VPWR VPWR sky130_fd_sc_hd__decap_3
XFILLER_35_257 VGND VGND VPWR VPWR sky130_fd_sc_hd__decap_3
XFILLER_35_279 VGND VGND VPWR VPWR sky130_fd_sc_hd__fill_1
XFILLER_90_363 VGND VGND VPWR VPWR sky130_fd_sc_hd__fill_1
XFILLER_90_374 VGND VGND VPWR VPWR sky130_fd_sc_hd__decap_3
XTAP_TAPCELL_ROW_18_466 VGND VPWR sky130_fd_sc_hd__tapvpwrvgnd_1
XFILLER_50_238 VGND VGND VPWR VPWR sky130_fd_sc_hd__decap_3
XFILLER_73_90 VGND VGND VPWR VPWR sky130_fd_sc_hd__decap_3
XFILLER_90_396 VGND VGND VPWR VPWR sky130_fd_sc_hd__decap_3
XFILLER_43_290 VGND VGND VPWR VPWR sky130_fd_sc_hd__decap_3
XFILLER_92_3 VGND VGND VPWR VPWR sky130_fd_sc_hd__decap_3
X_6680_ _6684_/A VGND VGND VPWR VPWR _6680_/Y sky130_fd_sc_hd__inv_2
X_3892_ _6771_/Q _3892_/A2 _3892_/B1 _6765_/Q VGND VGND VPWR VPWR _3892_/X sky130_fd_sc_hd__a22o_2
XTAP_TAPCELL_ROW_100_1450 VGND VPWR sky130_fd_sc_hd__tapvpwrvgnd_1
X_7301_ _7363_/CLK _7301_/D _6581_/Y VGND VGND VPWR VPWR _7301_/Q sky130_fd_sc_hd__dfrtp_2
X_4513_ _4513_/A0 _7291_/Q _4530_/S VGND VGND VPWR VPWR _7323_/D sky130_fd_sc_hd__mux2_2
X_7232_ _7359_/CLK _7232_/D _6512_/Y VGND VGND VPWR VPWR _7232_/Q sky130_fd_sc_hd__dfrtp_2
Xclkbuf_leaf_7_clk clkbuf_leaf_7_clk/A VGND VGND VPWR VPWR _7361_/CLK sky130_fd_sc_hd__clkbuf_16
X_4444_ _4396_/A _4444_/B VGND VGND VPWR VPWR _4444_/X sky130_fd_sc_hd__and2b_2
X_7163_ clkload3/A _7163_/D _6443_/Y VGND VGND VPWR VPWR _7163_/Q sky130_fd_sc_hd__dfrtp_2
X_4375_ _5003_/A _4374_/X _4988_/A VGND VGND VPWR VPWR _4375_/X sky130_fd_sc_hd__o21ba_2
XFILLER_98_430 VGND VGND VPWR VPWR sky130_fd_sc_hd__decap_3
X_7094_ clkload7/A _7094_/D _6374_/Y VGND VGND VPWR VPWR _7094_/Q sky130_fd_sc_hd__dfrtp_2
X_3326_ _3326_/A _3326_/B VGND VGND VPWR VPWR _5238_/B sky130_fd_sc_hd__nor2_2
XFILLER_98_474 VGND VGND VPWR VPWR sky130_fd_sc_hd__fill_2
XFILLER_100_413 VGND VGND VPWR VPWR sky130_fd_sc_hd__decap_3
XFILLER_100_424 VGND VGND VPWR VPWR sky130_fd_sc_hd__decap_3
XFILLER_112_262 VGND VGND VPWR VPWR sky130_fd_sc_hd__decap_3
XFILLER_112_295 VGND VGND VPWR VPWR sky130_fd_sc_hd__decap_3
XFILLER_58_338 VGND VGND VPWR VPWR sky130_fd_sc_hd__decap_3
XFILLER_85_102 VGND VGND VPWR VPWR sky130_fd_sc_hd__decap_3
XFILLER_85_124 VGND VGND VPWR VPWR sky130_fd_sc_hd__decap_3
XFILLER_100_457 VGND VGND VPWR VPWR sky130_fd_sc_hd__decap_3
XFILLER_100_468 VGND VGND VPWR VPWR sky130_fd_sc_hd__decap_3
XFILLER_73_319 VGND VGND VPWR VPWR sky130_fd_sc_hd__decap_3
XFILLER_26_246 VGND VGND VPWR VPWR sky130_fd_sc_hd__decap_3
XFILLER_66_393 VGND VGND VPWR VPWR sky130_fd_sc_hd__decap_3
XFILLER_26_257 VGND VGND VPWR VPWR sky130_fd_sc_hd__decap_3
XFILLER_53_27 VGND VGND VPWR VPWR sky130_fd_sc_hd__decap_3
XFILLER_81_352 VGND VGND VPWR VPWR sky130_fd_sc_hd__decap_3
XFILLER_41_238 VGND VGND VPWR VPWR sky130_fd_sc_hd__decap_3
XFILLER_81_396 VGND VGND VPWR VPWR sky130_fd_sc_hd__fill_1
X_6947_ _6966_/CLK _6947_/D VGND VGND VPWR VPWR _6947_/Q sky130_fd_sc_hd__dfxtp_2
X_6878_ _7383_/CLK _6878_/D VGND VGND VPWR VPWR _6878_/Q sky130_fd_sc_hd__dfxtp_2
XTAP_TAPCELL_ROW_114_1619 VGND VPWR sky130_fd_sc_hd__tapvpwrvgnd_1
XFILLER_108_579 VGND VGND VPWR VPWR sky130_fd_sc_hd__decap_3
XFILLER_78_46 VGND VGND VPWR VPWR sky130_fd_sc_hd__fill_1
XFILLER_78_57 VGND VGND VPWR VPWR sky130_fd_sc_hd__decap_3
XFILLER_89_441 VGND VGND VPWR VPWR sky130_fd_sc_hd__decap_3
Xhold670 _6802_/Q VGND VGND VPWR VPWR _6802_/D sky130_fd_sc_hd__dlygate4sd3_1
Xhold681 _6832_/Q VGND VGND VPWR VPWR _6832_/D sky130_fd_sc_hd__dlygate4sd3_1
XFILLER_103_240 VGND VGND VPWR VPWR sky130_fd_sc_hd__decap_3
XFILLER_89_452 VGND VGND VPWR VPWR sky130_fd_sc_hd__decap_3
Xhold692 _6847_/Q VGND VGND VPWR VPWR _6847_/D sky130_fd_sc_hd__dlygate4sd3_1
XFILLER_103_284 VGND VGND VPWR VPWR sky130_fd_sc_hd__decap_3
XFILLER_49_327 VGND VGND VPWR VPWR sky130_fd_sc_hd__decap_3
XFILLER_89_485 VGND VGND VPWR VPWR sky130_fd_sc_hd__decap_3
XFILLER_49_349 VGND VGND VPWR VPWR sky130_fd_sc_hd__decap_3
XFILLER_77_669 VGND VGND VPWR VPWR sky130_fd_sc_hd__decap_3
XFILLER_17_202 VGND VGND VPWR VPWR sky130_fd_sc_hd__decap_3
XFILLER_45_511 VGND VGND VPWR VPWR sky130_fd_sc_hd__fill_2
XFILLER_76_168 VGND VGND VPWR VPWR sky130_fd_sc_hd__decap_3
XFILLER_91_116 VGND VGND VPWR VPWR sky130_fd_sc_hd__decap_3
XFILLER_92_628 VGND VGND VPWR VPWR sky130_fd_sc_hd__fill_1
XFILLER_27_50 VGND VGND VPWR VPWR sky130_fd_sc_hd__decap_3
XFILLER_27_72 VGND VGND VPWR VPWR sky130_fd_sc_hd__decap_3
XFILLER_57_393 VGND VGND VPWR VPWR sky130_fd_sc_hd__decap_3
XFILLER_85_691 VGND VGND VPWR VPWR sky130_fd_sc_hd__fill_1
XFILLER_17_257 VGND VGND VPWR VPWR sky130_fd_sc_hd__decap_3
XFILLER_17_268 VGND VGND VPWR VPWR sky130_fd_sc_hd__decap_3
XFILLER_72_363 VGND VGND VPWR VPWR sky130_fd_sc_hd__fill_1
XFILLER_72_374 VGND VGND VPWR VPWR sky130_fd_sc_hd__decap_3
XFILLER_32_216 VGND VGND VPWR VPWR sky130_fd_sc_hd__decap_3
XFILLER_60_536 VGND VGND VPWR VPWR sky130_fd_sc_hd__decap_3
XFILLER_13_452 VGND VGND VPWR VPWR sky130_fd_sc_hd__fill_2
XFILLER_25_290 VGND VGND VPWR VPWR sky130_fd_sc_hd__decap_3
XTAP_TAPCELL_ROW_43_767 VGND VPWR sky130_fd_sc_hd__tapvpwrvgnd_1
XTAP_TAPCELL_ROW_15_436 VGND VPWR sky130_fd_sc_hd__tapvpwrvgnd_1
XFILLER_40_271 VGND VGND VPWR VPWR sky130_fd_sc_hd__decap_3
XFILLER_43_60 VGND VGND VPWR VPWR sky130_fd_sc_hd__decap_3
XFILLER_114_516 VGND VGND VPWR VPWR sky130_fd_sc_hd__decap_3
XFILLER_5_673 VGND VGND VPWR VPWR sky130_fd_sc_hd__fill_2
XFILLER_4_161 VGND VGND VPWR VPWR sky130_fd_sc_hd__decap_3
XFILLER_4_194 VGND VGND VPWR VPWR sky130_fd_sc_hd__fill_2
XFILLER_99_249 VGND VGND VPWR VPWR sky130_fd_sc_hd__decap_3
XFILLER_4_54 VGND VGND VPWR VPWR sky130_fd_sc_hd__decap_3
X_4160_ _7297_/Q _4501_/S _4430_/B1 _7169_/Q _4159_/X VGND VGND VPWR VPWR _4160_/X
+ sky130_fd_sc_hd__a221o_2
XFILLER_67_102 VGND VGND VPWR VPWR sky130_fd_sc_hd__decap_3
XFILLER_67_113 VGND VGND VPWR VPWR sky130_fd_sc_hd__decap_3
XFILLER_83_606 VGND VGND VPWR VPWR sky130_fd_sc_hd__fill_1
XFILLER_95_444 VGND VGND VPWR VPWR sky130_fd_sc_hd__decap_3
X_4091_ _7110_/Q _4434_/A2 _4434_/B1 _7142_/Q _4090_/X VGND VGND VPWR VPWR _4091_/X
+ sky130_fd_sc_hd__a221o_2
XFILLER_82_105 VGND VGND VPWR VPWR sky130_fd_sc_hd__decap_3
XFILLER_83_617 VGND VGND VPWR VPWR sky130_fd_sc_hd__decap_3
XFILLER_83_628 VGND VGND VPWR VPWR sky130_fd_sc_hd__decap_3
XFILLER_95_488 VGND VGND VPWR VPWR sky130_fd_sc_hd__decap_3
XFILLER_36_533 VGND VGND VPWR VPWR sky130_fd_sc_hd__fill_2
XFILLER_75_190 VGND VGND VPWR VPWR sky130_fd_sc_hd__decap_3
XFILLER_51_503 VGND VGND VPWR VPWR sky130_fd_sc_hd__fill_1
XFILLER_63_352 VGND VGND VPWR VPWR sky130_fd_sc_hd__decap_3
Xplace330 _5708_/S VGND VGND VPWR VPWR _5729_/S sky130_fd_sc_hd__buf_2
X_6801_ _7404_/CLK _6801_/D VGND VGND VPWR VPWR _6801_/Q sky130_fd_sc_hd__dfxtp_2
XFILLER_23_238 VGND VGND VPWR VPWR sky130_fd_sc_hd__fill_2
XFILLER_63_385 VGND VGND VPWR VPWR sky130_fd_sc_hd__decap_3
XFILLER_63_396 VGND VGND VPWR VPWR sky130_fd_sc_hd__decap_3
Xplace363 _3409_/X VGND VGND VPWR VPWR _4267_/B1 sky130_fd_sc_hd__buf_2
Xplace352 _4351_/A2 VGND VGND VPWR VPWR _4218_/A2 sky130_fd_sc_hd__buf_2
Xplace341 _5429_/S VGND VGND VPWR VPWR _5419_/S sky130_fd_sc_hd__buf_2
X_4993_ _4987_/A _4991_/Y _4992_/Y VGND VGND VPWR VPWR _4993_/X sky130_fd_sc_hd__o21a_2
XFILLER_51_569 VGND VGND VPWR VPWR sky130_fd_sc_hd__fill_1
Xplace385 _3378_/Y VGND VGND VPWR VPWR _4246_/B1 sky130_fd_sc_hd__buf_2
Xplace396 _5340_/S VGND VGND VPWR VPWR _5350_/S sky130_fd_sc_hd__buf_2
Xplace374 _3864_/S VGND VGND VPWR VPWR _5151_/A sky130_fd_sc_hd__buf_2
X_6732_ _6978_/CLK _6732_/D VGND VGND VPWR VPWR _6732_/Q sky130_fd_sc_hd__dfxtp_2
XFILLER_31_271 VGND VGND VPWR VPWR sky130_fd_sc_hd__decap_3
X_6663_ _6672_/A VGND VGND VPWR VPWR _6663_/Y sky130_fd_sc_hd__inv_2
X_3875_ hold991/X _5138_/S _3874_/X VGND VGND VPWR VPWR _7383_/D sky130_fd_sc_hd__o21a_2
X_6594_ _6635_/A VGND VGND VPWR VPWR _6594_/Y sky130_fd_sc_hd__inv_2
XFILLER_105_505 VGND VGND VPWR VPWR sky130_fd_sc_hd__decap_3
X_7215_ _7294_/CLK _7215_/D _6495_/Y VGND VGND VPWR VPWR _7215_/Q sky130_fd_sc_hd__dfrtp_2
X_7146_ _7307_/CLK _7146_/D _6426_/Y VGND VGND VPWR VPWR _7146_/Q sky130_fd_sc_hd__dfrtp_2
XFILLER_113_582 VGND VGND VPWR VPWR sky130_fd_sc_hd__decap_3
XFILLER_48_38 VGND VGND VPWR VPWR sky130_fd_sc_hd__decap_3
XFILLER_59_636 VGND VGND VPWR VPWR sky130_fd_sc_hd__decap_3
XFILLER_86_433 VGND VGND VPWR VPWR sky130_fd_sc_hd__decap_3
X_4358_ _4367_/A _4367_/B _4367_/C VGND VGND VPWR VPWR _5072_/B sky130_fd_sc_hd__a21bo_2
XFILLER_98_271 VGND VGND VPWR VPWR sky130_fd_sc_hd__decap_3
XFILLER_100_243 VGND VGND VPWR VPWR sky130_fd_sc_hd__decap_3
X_7077_ _7330_/CLK _7077_/D _6357_/Y VGND VGND VPWR VPWR _7077_/Q sky130_fd_sc_hd__dfrtp_2
X_4289_ _4537_/C _4289_/B VGND VGND VPWR VPWR _4649_/A sky130_fd_sc_hd__nand2_2
X_3309_ _3327_/A _3365_/A _3362_/A VGND VGND VPWR VPWR _3383_/B sky130_fd_sc_hd__or3_4
XFILLER_27_511 VGND VGND VPWR VPWR sky130_fd_sc_hd__decap_3
XFILLER_39_360 VGND VGND VPWR VPWR sky130_fd_sc_hd__decap_3
XFILLER_58_168 VGND VGND VPWR VPWR sky130_fd_sc_hd__decap_3
XFILLER_67_680 VGND VGND VPWR VPWR sky130_fd_sc_hd__decap_3
XFILLER_73_105 VGND VGND VPWR VPWR sky130_fd_sc_hd__decap_3
XFILLER_86_477 VGND VGND VPWR VPWR sky130_fd_sc_hd__decap_3
XFILLER_100_298 VGND VGND VPWR VPWR sky130_fd_sc_hd__fill_1
XFILLER_104_77 VGND VGND VPWR VPWR sky130_fd_sc_hd__decap_3
XFILLER_64_15 VGND VGND VPWR VPWR sky130_fd_sc_hd__fill_2
XFILLER_54_341 VGND VGND VPWR VPWR sky130_fd_sc_hd__decap_3
XFILLER_64_59 VGND VGND VPWR VPWR sky130_fd_sc_hd__fill_2
XFILLER_82_661 VGND VGND VPWR VPWR sky130_fd_sc_hd__decap_3
XFILLER_42_536 VGND VGND VPWR VPWR sky130_fd_sc_hd__fill_1
XFILLER_54_385 VGND VGND VPWR VPWR sky130_fd_sc_hd__decap_3
XFILLER_81_160 VGND VGND VPWR VPWR sky130_fd_sc_hd__decap_3
XFILLER_82_683 VGND VGND VPWR VPWR sky130_fd_sc_hd__fill_2
XTAP_TAPCELL_ROW_64_1017 VGND VPWR sky130_fd_sc_hd__tapvpwrvgnd_1
XFILLER_14_249 VGND VGND VPWR VPWR sky130_fd_sc_hd__decap_3
Xfanout20 _6632_/A VGND VGND VPWR VPWR _6567_/A sky130_fd_sc_hd__buf_2
Xfanout31 fanout38/X VGND VGND VPWR VPWR _6638_/A sky130_fd_sc_hd__clkdlybuf4s25_1
XFILLER_80_47 VGND VGND VPWR VPWR sky130_fd_sc_hd__decap_3
Xfanout42 _6547_/A VGND VGND VPWR VPWR _6578_/A sky130_fd_sc_hd__buf_2
Xfanout53 _6674_/A VGND VGND VPWR VPWR _6672_/A sky130_fd_sc_hd__buf_2
Xfanout64 fanout72/X VGND VGND VPWR VPWR _6683_/A sky130_fd_sc_hd__clkdlybuf4s25_1
XTAP_TAPCELL_ROW_40_726 VGND VPWR sky130_fd_sc_hd__tapvpwrvgnd_1
XFILLER_13_41 VGND VGND VPWR VPWR sky130_fd_sc_hd__decap_3
XFILLER_22_271 VGND VGND VPWR VPWR sky130_fd_sc_hd__decap_3
XFILLER_22_293 VGND VGND VPWR VPWR sky130_fd_sc_hd__decap_3
XTAP_TAPCELL_ROW_40_737 VGND VPWR sky130_fd_sc_hd__tapvpwrvgnd_1
XFILLER_13_63 VGND VGND VPWR VPWR sky130_fd_sc_hd__decap_3
XFILLER_108_321 VGND VGND VPWR VPWR sky130_fd_sc_hd__decap_3
XFILLER_13_85 VGND VGND VPWR VPWR sky130_fd_sc_hd__decap_3
XFILLER_6_448 VGND VGND VPWR VPWR sky130_fd_sc_hd__decap_3
XFILLER_6_459 VGND VGND VPWR VPWR sky130_fd_sc_hd__fill_1
XFILLER_89_12 VGND VGND VPWR VPWR sky130_fd_sc_hd__decap_3
XFILLER_89_34 VGND VGND VPWR VPWR sky130_fd_sc_hd__decap_3
XFILLER_108_365 VGND VGND VPWR VPWR sky130_fd_sc_hd__decap_3
XTAP_TAPCELL_ROW_20_494 VGND VPWR sky130_fd_sc_hd__tapvpwrvgnd_1
XFILLER_89_78 VGND VGND VPWR VPWR sky130_fd_sc_hd__decap_3
XTAP_TAPCELL_ROW_75_1157 VGND VPWR sky130_fd_sc_hd__tapvpwrvgnd_1
XTAP_TAPCELL_ROW_75_1146 VGND VPWR sky130_fd_sc_hd__tapvpwrvgnd_1
XFILLER_111_508 VGND VGND VPWR VPWR sky130_fd_sc_hd__decap_3
XFILLER_49_113 VGND VGND VPWR VPWR sky130_fd_sc_hd__decap_3
XFILLER_77_411 VGND VGND VPWR VPWR sky130_fd_sc_hd__decap_3
XFILLER_49_146 VGND VGND VPWR VPWR sky130_fd_sc_hd__decap_3
XFILLER_77_444 VGND VGND VPWR VPWR sky130_fd_sc_hd__decap_3
XFILLER_77_466 VGND VGND VPWR VPWR sky130_fd_sc_hd__decap_3
XFILLER_37_308 VGND VGND VPWR VPWR sky130_fd_sc_hd__decap_3
XFILLER_38_60 VGND VGND VPWR VPWR sky130_fd_sc_hd__decap_3
XTAP_TAPCELL_ROW_48_826 VGND VPWR sky130_fd_sc_hd__tapvpwrvgnd_1
XFILLER_58_691 VGND VGND VPWR VPWR sky130_fd_sc_hd__fill_1
XFILLER_64_138 VGND VGND VPWR VPWR sky130_fd_sc_hd__fill_2
XFILLER_92_458 VGND VGND VPWR VPWR sky130_fd_sc_hd__decap_3
XFILLER_33_503 VGND VGND VPWR VPWR sky130_fd_sc_hd__fill_1
XFILLER_45_352 VGND VGND VPWR VPWR sky130_fd_sc_hd__decap_3
XFILLER_45_396 VGND VGND VPWR VPWR sky130_fd_sc_hd__decap_3
XFILLER_60_322 VGND VGND VPWR VPWR sky130_fd_sc_hd__decap_3
XFILLER_73_683 VGND VGND VPWR VPWR sky130_fd_sc_hd__fill_1
XTAP_TAPCELL_ROW_86_1286 VGND VPWR sky130_fd_sc_hd__tapvpwrvgnd_1
XTAP_TAPCELL_ROW_28_583 VGND VPWR sky130_fd_sc_hd__tapvpwrvgnd_1
XFILLER_60_355 VGND VGND VPWR VPWR sky130_fd_sc_hd__decap_3
XFILLER_72_193 VGND VGND VPWR VPWR sky130_fd_sc_hd__decap_3
XFILLER_60_388 VGND VGND VPWR VPWR sky130_fd_sc_hd__decap_3
XFILLER_13_271 VGND VGND VPWR VPWR sky130_fd_sc_hd__decap_3
XFILLER_9_231 VGND VGND VPWR VPWR sky130_fd_sc_hd__decap_3
XFILLER_9_220 VGND VGND VPWR VPWR sky130_fd_sc_hd__decap_3
XFILLER_9_264 VGND VGND VPWR VPWR sky130_fd_sc_hd__decap_3
Xclkload12 _6978_/CLK VGND VGND VPWR VPWR clkload12/X sky130_fd_sc_hd__clkbuf_8
Xclkload23 _7396_/CLK VGND VGND VPWR VPWR clkload23/X sky130_fd_sc_hd__clkbuf_8
Xclkload34 _7198_/CLK VGND VGND VPWR VPWR clkload34/X sky130_fd_sc_hd__clkbuf_1
X_3591_ _3591_/A _3591_/B _3591_/C _3586_/D VGND VGND VPWR VPWR _3591_/Y sky130_fd_sc_hd__nor4b_2
XFILLER_9_297 VGND VGND VPWR VPWR sky130_fd_sc_hd__decap_3
XFILLER_55_3 VGND VGND VPWR VPWR sky130_fd_sc_hd__decap_3
XFILLER_5_470 VGND VGND VPWR VPWR sky130_fd_sc_hd__decap_3
XFILLER_102_508 VGND VGND VPWR VPWR sky130_fd_sc_hd__decap_3
XFILLER_114_346 VGND VGND VPWR VPWR sky130_fd_sc_hd__decap_3
XFILLER_114_379 VGND VGND VPWR VPWR sky130_fd_sc_hd__decap_3
X_7000_ _7368_/CLK _7000_/D _6280_/Y VGND VGND VPWR VPWR _7000_/Q sky130_fd_sc_hd__dfrtp_2
X_4212_ _7324_/Q _3964_/S _3378_/Y _7132_/Q VGND VGND VPWR VPWR _4212_/X sky130_fd_sc_hd__a22o_2
X_5192_ _5192_/A _5194_/B VGND VGND VPWR VPWR _7232_/D sky130_fd_sc_hd__and2_2
XFILLER_56_606 VGND VGND VPWR VPWR sky130_fd_sc_hd__fill_2
X_4143_ _4845_/A _4140_/X _4142_/X VGND VGND VPWR VPWR _4143_/X sky130_fd_sc_hd__a21o_2
XFILLER_110_563 VGND VGND VPWR VPWR sky130_fd_sc_hd__decap_3
XFILLER_68_477 VGND VGND VPWR VPWR sky130_fd_sc_hd__decap_3
XFILLER_68_488 VGND VGND VPWR VPWR sky130_fd_sc_hd__decap_3
XFILLER_83_425 VGND VGND VPWR VPWR sky130_fd_sc_hd__decap_3
X_4074_ _7083_/Q _4432_/A2 _4432_/B1 _4073_/X VGND VGND VPWR VPWR _4451_/A sky130_fd_sc_hd__o211ai_2
XFILLER_55_138 VGND VGND VPWR VPWR sky130_fd_sc_hd__decap_3
XFILLER_36_330 VGND VGND VPWR VPWR sky130_fd_sc_hd__decap_3
XFILLER_70_108 VGND VGND VPWR VPWR sky130_fd_sc_hd__decap_3
XFILLER_51_311 VGND VGND VPWR VPWR sky130_fd_sc_hd__decap_3
XFILLER_91_480 VGND VGND VPWR VPWR sky130_fd_sc_hd__decap_3
XFILLER_51_377 VGND VGND VPWR VPWR sky130_fd_sc_hd__decap_3
X_6715_ _7404_/CLK _6715_/D VGND VGND VPWR VPWR _6715_/Q sky130_fd_sc_hd__dfxtp_2
X_4976_ _6992_/Q _5001_/A _6993_/Q VGND VGND VPWR VPWR _4977_/B sky130_fd_sc_hd__a21oi_2
XFILLER_51_399 VGND VGND VPWR VPWR sky130_fd_sc_hd__decap_3
X_3927_ _3629_/A _3926_/X _5104_/A VGND VGND VPWR VPWR _3927_/X sky130_fd_sc_hd__a21o_2
Xclkload6 clkload6/A VGND VGND VPWR VPWR clkload6/Y sky130_fd_sc_hd__clkinv_4
X_6646_ _6684_/A VGND VGND VPWR VPWR _6646_/Y sky130_fd_sc_hd__inv_2
X_3858_ _6698_/Q _3863_/A2 _3858_/B1 _6876_/Q VGND VGND VPWR VPWR _3858_/X sky130_fd_sc_hd__a22o_2
X_6577_ _6642_/A VGND VGND VPWR VPWR _6577_/Y sky130_fd_sc_hd__inv_2
X_3789_ _3728_/Y _3781_/X _3783_/X _3725_/X _3788_/X VGND VGND VPWR VPWR _3789_/X
+ sky130_fd_sc_hd__a221o_2
XFILLER_105_324 VGND VGND VPWR VPWR sky130_fd_sc_hd__decap_3
Xoutput550 _6981_/Q VGND VGND VPWR VPWR pc_out[4] sky130_fd_sc_hd__clkdlybuf4s25_1
XFILLER_105_379 VGND VGND VPWR VPWR sky130_fd_sc_hd__decap_3
XFILLER_59_411 VGND VGND VPWR VPWR sky130_fd_sc_hd__decap_3
XFILLER_59_444 VGND VGND VPWR VPWR sky130_fd_sc_hd__decap_3
XFILLER_86_230 VGND VGND VPWR VPWR sky130_fd_sc_hd__decap_3
X_7129_ clkload6/A _7129_/D _6409_/Y VGND VGND VPWR VPWR _7129_/Q sky130_fd_sc_hd__dfrtp_2
XFILLER_19_308 VGND VGND VPWR VPWR sky130_fd_sc_hd__decap_3
XFILLER_46_105 VGND VGND VPWR VPWR sky130_fd_sc_hd__decap_3
XFILLER_47_617 VGND VGND VPWR VPWR sky130_fd_sc_hd__fill_1
XTAP_TAPCELL_ROW_70_1087 VGND VPWR sky130_fd_sc_hd__tapvpwrvgnd_1
XFILLER_101_596 VGND VGND VPWR VPWR sky130_fd_sc_hd__fill_2
XFILLER_46_127 VGND VGND VPWR VPWR sky130_fd_sc_hd__decap_3
XFILLER_74_458 VGND VGND VPWR VPWR sky130_fd_sc_hd__decap_3
XFILLER_86_285 VGND VGND VPWR VPWR sky130_fd_sc_hd__fill_2
XFILLER_27_352 VGND VGND VPWR VPWR sky130_fd_sc_hd__decap_3
XFILLER_61_108 VGND VGND VPWR VPWR sky130_fd_sc_hd__decap_3
XFILLER_82_480 VGND VGND VPWR VPWR sky130_fd_sc_hd__decap_3
XFILLER_91_57 VGND VGND VPWR VPWR sky130_fd_sc_hd__decap_3
XTAP_TAPCELL_ROW_53_884 VGND VPWR sky130_fd_sc_hd__tapvpwrvgnd_1
XTAP_TAPCELL_ROW_25_553 VGND VPWR sky130_fd_sc_hd__tapvpwrvgnd_1
XFILLER_24_62 VGND VGND VPWR VPWR sky130_fd_sc_hd__fill_1
XFILLER_24_95 VGND VGND VPWR VPWR sky130_fd_sc_hd__decap_3
XFILLER_10_263 VGND VGND VPWR VPWR sky130_fd_sc_hd__decap_3
XFILLER_6_212 VGND VGND VPWR VPWR sky130_fd_sc_hd__decap_3
XFILLER_40_50 VGND VGND VPWR VPWR sky130_fd_sc_hd__decap_3
XFILLER_6_245 VGND VGND VPWR VPWR sky130_fd_sc_hd__decap_3
XFILLER_6_278 VGND VGND VPWR VPWR sky130_fd_sc_hd__fill_2
XFILLER_108_173 VGND VGND VPWR VPWR sky130_fd_sc_hd__decap_3
XFILLER_97_517 VGND VGND VPWR VPWR sky130_fd_sc_hd__decap_3
XFILLER_111_327 VGND VGND VPWR VPWR sky130_fd_sc_hd__decap_3
XFILLER_69_219 VGND VGND VPWR VPWR sky130_fd_sc_hd__decap_3
XFILLER_2_495 VGND VGND VPWR VPWR sky130_fd_sc_hd__fill_1
XFILLER_65_414 VGND VGND VPWR VPWR sky130_fd_sc_hd__decap_3
XFILLER_77_252 VGND VGND VPWR VPWR sky130_fd_sc_hd__decap_3
XFILLER_77_274 VGND VGND VPWR VPWR sky130_fd_sc_hd__decap_3
XTAP_TAPCELL_ROW_88_1304 VGND VPWR sky130_fd_sc_hd__tapvpwrvgnd_1
XFILLER_37_116 VGND VGND VPWR VPWR sky130_fd_sc_hd__decap_3
XFILLER_65_447 VGND VGND VPWR VPWR sky130_fd_sc_hd__fill_1
XFILLER_80_406 VGND VGND VPWR VPWR sky130_fd_sc_hd__decap_3
XFILLER_18_363 VGND VGND VPWR VPWR sky130_fd_sc_hd__fill_1
XFILLER_61_620 VGND VGND VPWR VPWR sky130_fd_sc_hd__decap_3
XFILLER_18_396 VGND VGND VPWR VPWR sky130_fd_sc_hd__decap_3
XFILLER_33_333 VGND VGND VPWR VPWR sky130_fd_sc_hd__decap_3
XFILLER_33_355 VGND VGND VPWR VPWR sky130_fd_sc_hd__decap_3
XFILLER_45_182 VGND VGND VPWR VPWR sky130_fd_sc_hd__decap_3
XFILLER_61_653 VGND VGND VPWR VPWR sky130_fd_sc_hd__decap_3
X_4830_ _4646_/Y _4827_/A _4829_/Y VGND VGND VPWR VPWR _4830_/X sky130_fd_sc_hd__o21a_2
XFILLER_60_141 VGND VGND VPWR VPWR sky130_fd_sc_hd__fill_1
X_4761_ _4762_/B _4761_/B _4761_/C VGND VGND VPWR VPWR _4761_/Y sky130_fd_sc_hd__nand3_2
X_6500_ _6568_/A VGND VGND VPWR VPWR _6500_/Y sky130_fd_sc_hd__inv_2
X_4692_ _7006_/Q _4749_/B VGND VGND VPWR VPWR _4750_/B sky130_fd_sc_hd__and2_2
X_3712_ _3746_/B VGND VGND VPWR VPWR _3741_/B sky130_fd_sc_hd__inv_2
XTAP_TAPCELL_ROW_99_1444 VGND VPWR sky130_fd_sc_hd__tapvpwrvgnd_1
X_6431_ _6637_/A VGND VGND VPWR VPWR _6431_/Y sky130_fd_sc_hd__inv_2
X_6362_ _6385_/A VGND VGND VPWR VPWR _6362_/Y sky130_fd_sc_hd__inv_2
XFILLER_114_110 VGND VGND VPWR VPWR sky130_fd_sc_hd__fill_1
X_3574_ _7348_/Q _4338_/B1 _3573_/X _3556_/A VGND VGND VPWR VPWR _3574_/X sky130_fd_sc_hd__a211o_2
XFILLER_114_132 VGND VGND VPWR VPWR sky130_fd_sc_hd__decap_3
X_6293_ _6535_/A VGND VGND VPWR VPWR _6293_/Y sky130_fd_sc_hd__inv_2
XFILLER_102_327 VGND VGND VPWR VPWR sky130_fd_sc_hd__decap_3
XFILLER_88_539 VGND VGND VPWR VPWR sky130_fd_sc_hd__decap_3
XFILLER_29_29 VGND VGND VPWR VPWR sky130_fd_sc_hd__decap_3
XFILLER_68_230 VGND VGND VPWR VPWR sky130_fd_sc_hd__decap_3
X_5175_ _5175_/A _5190_/B VGND VGND VPWR VPWR _7240_/D sky130_fd_sc_hd__and2_2
XFILLER_56_414 VGND VGND VPWR VPWR sky130_fd_sc_hd__decap_3
XFILLER_96_572 VGND VGND VPWR VPWR sky130_fd_sc_hd__decap_3
X_4126_ _4126_/A _4125_/X VGND VGND VPWR VPWR _4890_/B sky130_fd_sc_hd__or2b_2
XFILLER_28_116 VGND VGND VPWR VPWR sky130_fd_sc_hd__decap_3
XFILLER_68_285 VGND VGND VPWR VPWR sky130_fd_sc_hd__decap_3
XFILLER_83_211 VGND VGND VPWR VPWR sky130_fd_sc_hd__decap_3
XFILLER_45_17 VGND VGND VPWR VPWR sky130_fd_sc_hd__decap_3
XFILLER_56_458 VGND VGND VPWR VPWR sky130_fd_sc_hd__fill_2
XFILLER_83_255 VGND VGND VPWR VPWR sky130_fd_sc_hd__decap_3
X_4057_ _7308_/Q _4486_/S _4399_/A2 _7372_/Q _4429_/C1 VGND VGND VPWR VPWR _4057_/X
+ sky130_fd_sc_hd__a221o_2
XFILLER_43_119 VGND VGND VPWR VPWR sky130_fd_sc_hd__decap_3
XFILLER_64_480 VGND VGND VPWR VPWR sky130_fd_sc_hd__decap_3
XTAP_TAPCELL_ROW_108_1551 VGND VPWR sky130_fd_sc_hd__tapvpwrvgnd_1
XFILLER_101_23 VGND VGND VPWR VPWR sky130_fd_sc_hd__decap_3
XFILLER_36_182 VGND VGND VPWR VPWR sky130_fd_sc_hd__decap_3
XFILLER_52_653 VGND VGND VPWR VPWR sky130_fd_sc_hd__fill_1
XFILLER_64_491 VGND VGND VPWR VPWR sky130_fd_sc_hd__decap_3
XFILLER_24_388 VGND VGND VPWR VPWR sky130_fd_sc_hd__decap_3
XFILLER_51_163 VGND VGND VPWR VPWR sky130_fd_sc_hd__decap_3
XFILLER_101_78 VGND VGND VPWR VPWR sky130_fd_sc_hd__decap_3
XFILLER_51_185 VGND VGND VPWR VPWR sky130_fd_sc_hd__decap_3
XFILLER_61_27 VGND VGND VPWR VPWR sky130_fd_sc_hd__decap_3
X_4959_ _6993_/Q _4958_/Y _6994_/Q VGND VGND VPWR VPWR _4960_/C sky130_fd_sc_hd__a21oi_2
XTAP_TAPCELL_ROW_22_512 VGND VPWR sky130_fd_sc_hd__tapvpwrvgnd_1
XTAP_TAPCELL_ROW_50_854 VGND VPWR sky130_fd_sc_hd__tapvpwrvgnd_1
X_6629_ _6660_/A VGND VGND VPWR VPWR _6629_/Y sky130_fd_sc_hd__inv_2
XFILLER_106_622 VGND VGND VPWR VPWR sky130_fd_sc_hd__decap_3
XFILLER_3_204 VGND VGND VPWR VPWR sky130_fd_sc_hd__decap_3
XFILLER_106_666 VGND VGND VPWR VPWR sky130_fd_sc_hd__decap_3
XTAP_TAPCELL_ROW_72_1116 VGND VPWR sky130_fd_sc_hd__tapvpwrvgnd_1
XFILLER_105_187 VGND VGND VPWR VPWR sky130_fd_sc_hd__decap_3
XFILLER_10_75 VGND VGND VPWR VPWR sky130_fd_sc_hd__fill_1
XFILLER_79_528 VGND VGND VPWR VPWR sky130_fd_sc_hd__decap_3
XFILLER_86_35 VGND VGND VPWR VPWR sky130_fd_sc_hd__decap_3
XFILLER_94_509 VGND VGND VPWR VPWR sky130_fd_sc_hd__decap_3
XFILLER_101_360 VGND VGND VPWR VPWR sky130_fd_sc_hd__decap_3
XFILLER_19_40 VGND VGND VPWR VPWR sky130_fd_sc_hd__decap_3
XFILLER_47_414 VGND VGND VPWR VPWR sky130_fd_sc_hd__decap_3
XFILLER_59_252 VGND VGND VPWR VPWR sky130_fd_sc_hd__fill_2
XFILLER_86_68 VGND VGND VPWR VPWR sky130_fd_sc_hd__decap_3
XFILLER_87_561 VGND VGND VPWR VPWR sky130_fd_sc_hd__decap_3
XFILLER_101_393 VGND VGND VPWR VPWR sky130_fd_sc_hd__decap_3
XFILLER_59_296 VGND VGND VPWR VPWR sky130_fd_sc_hd__decap_3
XFILLER_74_200 VGND VGND VPWR VPWR sky130_fd_sc_hd__decap_3
XTAP_TAPCELL_ROW_58_943 VGND VPWR sky130_fd_sc_hd__tapvpwrvgnd_1
XFILLER_47_458 VGND VGND VPWR VPWR sky130_fd_sc_hd__decap_3
XFILLER_62_406 VGND VGND VPWR VPWR sky130_fd_sc_hd__decap_3
XFILLER_28_672 VGND VGND VPWR VPWR sky130_fd_sc_hd__decap_3
XFILLER_34_108 VGND VGND VPWR VPWR sky130_fd_sc_hd__decap_3
XFILLER_62_439 VGND VGND VPWR VPWR sky130_fd_sc_hd__decap_3
XFILLER_74_299 VGND VGND VPWR VPWR sky130_fd_sc_hd__decap_3
XTAP_TAPCELL_ROW_2_281 VGND VPWR sky130_fd_sc_hd__tapvpwrvgnd_1
XTAP_TAPCELL_ROW_2_270 VGND VPWR sky130_fd_sc_hd__tapvpwrvgnd_1
XFILLER_15_322 VGND VGND VPWR VPWR sky130_fd_sc_hd__decap_3
XFILLER_42_130 VGND VGND VPWR VPWR sky130_fd_sc_hd__fill_1
XFILLER_43_642 VGND VGND VPWR VPWR sky130_fd_sc_hd__fill_2
XTAP_TAPCELL_ROW_83_1245 VGND VPWR sky130_fd_sc_hd__tapvpwrvgnd_1
XFILLER_15_355 VGND VGND VPWR VPWR sky130_fd_sc_hd__decap_3
XFILLER_70_450 VGND VGND VPWR VPWR sky130_fd_sc_hd__decap_3
XFILLER_42_185 VGND VGND VPWR VPWR sky130_fd_sc_hd__decap_3
XFILLER_70_483 VGND VGND VPWR VPWR sky130_fd_sc_hd__decap_3
XFILLER_30_347 VGND VGND VPWR VPWR sky130_fd_sc_hd__decap_3
XFILLER_89_9 VGND VGND VPWR VPWR sky130_fd_sc_hd__decap_3
XFILLER_11_561 VGND VGND VPWR VPWR sky130_fd_sc_hd__fill_1
XTAP_TAPCELL_ROW_94_1374 VGND VPWR sky130_fd_sc_hd__tapvpwrvgnd_1
XTAP_TAPCELL_ROW_94_1385 VGND VPWR sky130_fd_sc_hd__tapvpwrvgnd_1
XFILLER_111_113 VGND VGND VPWR VPWR sky130_fd_sc_hd__decap_3
XFILLER_111_135 VGND VGND VPWR VPWR sky130_fd_sc_hd__decap_3
XFILLER_112_636 VGND VGND VPWR VPWR sky130_fd_sc_hd__fill_2
XFILLER_111_179 VGND VGND VPWR VPWR sky130_fd_sc_hd__decap_3
XFILLER_18_3 VGND VGND VPWR VPWR sky130_fd_sc_hd__decap_3
XFILLER_65_211 VGND VGND VPWR VPWR sky130_fd_sc_hd__fill_2
XFILLER_78_583 VGND VGND VPWR VPWR sky130_fd_sc_hd__decap_3
XFILLER_65_266 VGND VGND VPWR VPWR sky130_fd_sc_hd__decap_3
XFILLER_93_564 VGND VGND VPWR VPWR sky130_fd_sc_hd__fill_2
X_6980_ _7364_/CLK _6980_/D _6260_/Y VGND VGND VPWR VPWR _6980_/Q sky130_fd_sc_hd__dfrtp_2
XFILLER_25_119 VGND VGND VPWR VPWR sky130_fd_sc_hd__decap_3
XFILLER_80_225 VGND VGND VPWR VPWR sky130_fd_sc_hd__decap_3
XFILLER_93_597 VGND VGND VPWR VPWR sky130_fd_sc_hd__decap_3
XFILLER_18_193 VGND VGND VPWR VPWR sky130_fd_sc_hd__decap_3
XFILLER_34_642 VGND VGND VPWR VPWR sky130_fd_sc_hd__fill_2
XFILLER_46_480 VGND VGND VPWR VPWR sky130_fd_sc_hd__decap_3
XFILLER_33_141 VGND VGND VPWR VPWR sky130_fd_sc_hd__decap_3
XFILLER_61_461 VGND VGND VPWR VPWR sky130_fd_sc_hd__decap_3
XFILLER_21_325 VGND VGND VPWR VPWR sky130_fd_sc_hd__fill_1
XFILLER_33_196 VGND VGND VPWR VPWR sky130_fd_sc_hd__decap_3
X_4813_ _4813_/A _4813_/B VGND VGND VPWR VPWR _4813_/Y sky130_fd_sc_hd__nand2_2
X_4744_ _4938_/A _4744_/B VGND VGND VPWR VPWR _4744_/Y sky130_fd_sc_hd__nor2_2
XTAP_TAPCELL_ROW_103_1492 VGND VPWR sky130_fd_sc_hd__tapvpwrvgnd_1
XFILLER_107_419 VGND VGND VPWR VPWR sky130_fd_sc_hd__fill_1
X_4675_ _3757_/S _3469_/B _3564_/X _3449_/A _6984_/Q VGND VGND VPWR VPWR _5067_/B
+ sky130_fd_sc_hd__o2111a_2
X_7394_ _7394_/CLK _7394_/D _6674_/Y VGND VGND VPWR VPWR _7394_/Q sky130_fd_sc_hd__dfrtp_2
X_6414_ _6606_/A VGND VGND VPWR VPWR _6414_/Y sky130_fd_sc_hd__inv_2
X_3626_ _3616_/Y _3617_/X _3625_/X VGND VGND VPWR VPWR _3733_/C sky130_fd_sc_hd__a21oi_4
XFILLER_115_452 VGND VGND VPWR VPWR sky130_fd_sc_hd__decap_3
X_6345_ _6540_/A VGND VGND VPWR VPWR _6345_/Y sky130_fd_sc_hd__inv_2
X_3557_ _7221_/Q _3377_/X _4348_/B1 _7125_/Q _3556_/X VGND VGND VPWR VPWR _3557_/X
+ sky130_fd_sc_hd__a221o_2
XFILLER_88_303 VGND VGND VPWR VPWR sky130_fd_sc_hd__decap_3
X_6276_ _6652_/A VGND VGND VPWR VPWR _6276_/Y sky130_fd_sc_hd__inv_2
XFILLER_102_124 VGND VGND VPWR VPWR sky130_fd_sc_hd__decap_3
XFILLER_88_347 VGND VGND VPWR VPWR sky130_fd_sc_hd__decap_3
X_5227_ _5227_/A1 _5217_/B _5655_/B VGND VGND VPWR VPWR _7215_/D sky130_fd_sc_hd__a21o_2
X_3488_ _7279_/Q _4534_/S VGND VGND VPWR VPWR _3488_/X sky130_fd_sc_hd__and2_2
XFILLER_69_561 VGND VGND VPWR VPWR sky130_fd_sc_hd__fill_2
XFILLER_29_425 VGND VGND VPWR VPWR sky130_fd_sc_hd__decap_3
XFILLER_56_200 VGND VGND VPWR VPWR sky130_fd_sc_hd__decap_3
XFILLER_84_531 VGND VGND VPWR VPWR sky130_fd_sc_hd__fill_1
XFILLER_96_380 VGND VGND VPWR VPWR sky130_fd_sc_hd__decap_3
XFILLER_56_233 VGND VGND VPWR VPWR sky130_fd_sc_hd__decap_3
XFILLER_84_542 VGND VGND VPWR VPWR sky130_fd_sc_hd__decap_3
XFILLER_84_564 VGND VGND VPWR VPWR sky130_fd_sc_hd__decap_3
X_5089_ _3618_/C _4315_/A _5086_/A _5101_/A _5088_/X VGND VGND VPWR VPWR _5089_/Y
+ sky130_fd_sc_hd__o221ai_2
X_4109_ _4376_/A _4141_/A _4141_/B _4142_/C VGND VGND VPWR VPWR _4109_/X sky130_fd_sc_hd__o31a_2
XFILLER_16_108 VGND VGND VPWR VPWR sky130_fd_sc_hd__decap_3
XFILLER_16_119 VGND VGND VPWR VPWR sky130_fd_sc_hd__decap_3
XFILLER_56_277 VGND VGND VPWR VPWR sky130_fd_sc_hd__decap_3
XFILLER_71_214 VGND VGND VPWR VPWR sky130_fd_sc_hd__decap_3
XTAP_TAPCELL_ROW_55_913 VGND VPWR sky130_fd_sc_hd__tapvpwrvgnd_1
XFILLER_112_77 VGND VGND VPWR VPWR sky130_fd_sc_hd__fill_2
XFILLER_71_225 VGND VGND VPWR VPWR sky130_fd_sc_hd__decap_3
XFILLER_71_258 VGND VGND VPWR VPWR sky130_fd_sc_hd__decap_3
XFILLER_72_15 VGND VGND VPWR VPWR sky130_fd_sc_hd__decap_3
XFILLER_24_141 VGND VGND VPWR VPWR sky130_fd_sc_hd__decap_3
XFILLER_72_59 VGND VGND VPWR VPWR sky130_fd_sc_hd__decap_3
XFILLER_12_336 VGND VGND VPWR VPWR sky130_fd_sc_hd__decap_3
XFILLER_24_174 VGND VGND VPWR VPWR sky130_fd_sc_hd__decap_3
XTAP_TAPCELL_ROW_35_670 VGND VPWR sky130_fd_sc_hd__tapvpwrvgnd_1
XFILLER_8_307 VGND VGND VPWR VPWR sky130_fd_sc_hd__fill_1
XFILLER_20_380 VGND VGND VPWR VPWR sky130_fd_sc_hd__decap_3
XFILLER_21_63 VGND VGND VPWR VPWR sky130_fd_sc_hd__fill_1
XFILLER_106_430 VGND VGND VPWR VPWR sky130_fd_sc_hd__decap_3
XFILLER_21_74 VGND VGND VPWR VPWR sky130_fd_sc_hd__decap_3
XFILLER_97_12 VGND VGND VPWR VPWR sky130_fd_sc_hd__decap_3
XFILLER_106_474 VGND VGND VPWR VPWR sky130_fd_sc_hd__fill_2
XFILLER_79_303 VGND VGND VPWR VPWR sky130_fd_sc_hd__decap_3
XFILLER_97_45 VGND VGND VPWR VPWR sky130_fd_sc_hd__decap_3
XFILLER_106_496 VGND VGND VPWR VPWR sky130_fd_sc_hd__fill_1
XTAP_TAPCELL_ROW_7_340 VGND VPWR sky130_fd_sc_hd__tapvpwrvgnd_1
XFILLER_79_369 VGND VGND VPWR VPWR sky130_fd_sc_hd__decap_3
XFILLER_47_211 VGND VGND VPWR VPWR sky130_fd_sc_hd__decap_3
XFILLER_75_531 VGND VGND VPWR VPWR sky130_fd_sc_hd__decap_3
XFILLER_87_391 VGND VGND VPWR VPWR sky130_fd_sc_hd__fill_1
XFILLER_94_339 VGND VGND VPWR VPWR sky130_fd_sc_hd__decap_3
XFILLER_47_255 VGND VGND VPWR VPWR sky130_fd_sc_hd__decap_3
XFILLER_75_564 VGND VGND VPWR VPWR sky130_fd_sc_hd__decap_3
XFILLER_47_277 VGND VGND VPWR VPWR sky130_fd_sc_hd__decap_3
XFILLER_75_597 VGND VGND VPWR VPWR sky130_fd_sc_hd__decap_3
XFILLER_90_501 VGND VGND VPWR VPWR sky130_fd_sc_hd__decap_3
XFILLER_90_523 VGND VGND VPWR VPWR sky130_fd_sc_hd__decap_3
XFILLER_28_480 VGND VGND VPWR VPWR sky130_fd_sc_hd__decap_3
XFILLER_62_225 VGND VGND VPWR VPWR sky130_fd_sc_hd__decap_3
XFILLER_16_653 VGND VGND VPWR VPWR sky130_fd_sc_hd__fill_2
XFILLER_90_589 VGND VGND VPWR VPWR sky130_fd_sc_hd__decap_3
XFILLER_15_196 VGND VGND VPWR VPWR sky130_fd_sc_hd__decap_3
XFILLER_30_100 VGND VGND VPWR VPWR sky130_fd_sc_hd__fill_1
XFILLER_30_111 VGND VGND VPWR VPWR sky130_fd_sc_hd__decap_3
XFILLER_30_144 VGND VGND VPWR VPWR sky130_fd_sc_hd__decap_3
XFILLER_62_70 VGND VGND VPWR VPWR sky130_fd_sc_hd__decap_3
XFILLER_70_291 VGND VGND VPWR VPWR sky130_fd_sc_hd__decap_3
XFILLER_87_6 VGND VGND VPWR VPWR sky130_fd_sc_hd__decap_3
XFILLER_30_177 VGND VGND VPWR VPWR sky130_fd_sc_hd__decap_3
XFILLER_7_32 VGND VGND VPWR VPWR sky130_fd_sc_hd__decap_3
XFILLER_7_340 VGND VGND VPWR VPWR sky130_fd_sc_hd__decap_3
XFILLER_7_54 VGND VGND VPWR VPWR sky130_fd_sc_hd__fill_2
XTAP_TAPCELL_ROW_96_1403 VGND VPWR sky130_fd_sc_hd__tapvpwrvgnd_1
XFILLER_7_373 VGND VGND VPWR VPWR sky130_fd_sc_hd__decap_3
X_4460_ _4460_/A _4460_/B VGND VGND VPWR VPWR _4460_/Y sky130_fd_sc_hd__nand2_2
XFILLER_109_290 VGND VGND VPWR VPWR sky130_fd_sc_hd__decap_3
X_4391_ _7401_/Q _4437_/B1 _4436_/B1 _7177_/Q _4390_/X VGND VGND VPWR VPWR _4391_/X
+ sky130_fd_sc_hd__a221o_2
X_3342_ _3561_/B _3561_/A VGND VGND VPWR VPWR _5118_/D sky130_fd_sc_hd__nand2b_4
XFILLER_98_623 VGND VGND VPWR VPWR sky130_fd_sc_hd__decap_3
XFILLER_112_433 VGND VGND VPWR VPWR sky130_fd_sc_hd__decap_3
XFILLER_97_122 VGND VGND VPWR VPWR sky130_fd_sc_hd__decap_3
XFILLER_98_645 VGND VGND VPWR VPWR sky130_fd_sc_hd__decap_3
XFILLER_112_466 VGND VGND VPWR VPWR sky130_fd_sc_hd__fill_2
XFILLER_112_477 VGND VGND VPWR VPWR sky130_fd_sc_hd__decap_3
XFILLER_97_166 VGND VGND VPWR VPWR sky130_fd_sc_hd__fill_2
XFILLER_100_628 VGND VGND VPWR VPWR sky130_fd_sc_hd__decap_3
XFILLER_38_200 VGND VGND VPWR VPWR sky130_fd_sc_hd__fill_2
XFILLER_38_211 VGND VGND VPWR VPWR sky130_fd_sc_hd__decap_3
XFILLER_85_328 VGND VGND VPWR VPWR sky130_fd_sc_hd__decap_3
Xhold1007 _7253_/Q VGND VGND VPWR VPWR _5126_/A0 sky130_fd_sc_hd__dlygate4sd3_1
Xhold1018 _7393_/Q VGND VGND VPWR VPWR _3770_/A1 sky130_fd_sc_hd__dlygate4sd3_1
Xhold1029 _7260_/Q VGND VGND VPWR VPWR _5028_/A0 sky130_fd_sc_hd__dlygate4sd3_1
X_5012_ _5012_/A0 _5011_/X _5028_/S VGND VGND VPWR VPWR _7261_/D sky130_fd_sc_hd__mux2_2
XFILLER_66_531 VGND VGND VPWR VPWR sky130_fd_sc_hd__fill_1
XFILLER_66_542 VGND VGND VPWR VPWR sky130_fd_sc_hd__decap_3
XFILLER_38_277 VGND VGND VPWR VPWR sky130_fd_sc_hd__decap_3
XFILLER_81_512 VGND VGND VPWR VPWR sky130_fd_sc_hd__fill_1
XFILLER_81_523 VGND VGND VPWR VPWR sky130_fd_sc_hd__decap_3
XFILLER_93_361 VGND VGND VPWR VPWR sky130_fd_sc_hd__decap_3
XFILLER_19_480 VGND VGND VPWR VPWR sky130_fd_sc_hd__decap_3
XFILLER_38_299 VGND VGND VPWR VPWR sky130_fd_sc_hd__decap_3
XFILLER_53_225 VGND VGND VPWR VPWR sky130_fd_sc_hd__decap_3
XFILLER_81_556 VGND VGND VPWR VPWR sky130_fd_sc_hd__decap_3
X_6963_ _6978_/CLK _6963_/D VGND VGND VPWR VPWR _6963_/Q sky130_fd_sc_hd__dfxtp_2
XTAP_TAPCELL_ROW_105_1510 VGND VPWR sky130_fd_sc_hd__tapvpwrvgnd_1
XFILLER_81_567 VGND VGND VPWR VPWR sky130_fd_sc_hd__fill_2
X_6894_ _7198_/CLK _6894_/D VGND VGND VPWR VPWR _6894_/Q sky130_fd_sc_hd__dfxtp_2
XFILLER_21_122 VGND VGND VPWR VPWR sky130_fd_sc_hd__fill_2
XFILLER_21_133 VGND VGND VPWR VPWR sky130_fd_sc_hd__decap_3
XFILLER_22_645 VGND VGND VPWR VPWR sky130_fd_sc_hd__fill_2
XFILLER_42_18 VGND VGND VPWR VPWR sky130_fd_sc_hd__fill_1
XFILLER_42_29 VGND VGND VPWR VPWR sky130_fd_sc_hd__decap_3
XTAP_TAPCELL_ROW_32_640 VGND VPWR sky130_fd_sc_hd__tapvpwrvgnd_1
XFILLER_22_689 VGND VGND VPWR VPWR sky130_fd_sc_hd__decap_3
XTAP_TAPCELL_ROW_60_971 VGND VPWR sky130_fd_sc_hd__tapvpwrvgnd_1
XFILLER_21_199 VGND VGND VPWR VPWR sky130_fd_sc_hd__decap_3
X_4727_ _7007_/Q _4750_/B _4983_/A VGND VGND VPWR VPWR _4728_/B sky130_fd_sc_hd__o21a_2
XFILLER_107_205 VGND VGND VPWR VPWR sky130_fd_sc_hd__decap_3
X_4658_ _4658_/A _4658_/B VGND VGND VPWR VPWR _4658_/Y sky130_fd_sc_hd__nand2_2
XFILLER_107_249 VGND VGND VPWR VPWR sky130_fd_sc_hd__fill_2
Xhold830 _6780_/Q VGND VGND VPWR VPWR _6780_/D sky130_fd_sc_hd__dlygate4sd3_1
X_3609_ _5071_/A _5114_/A VGND VGND VPWR VPWR _3610_/B sky130_fd_sc_hd__nand2_2
XTAP_TAPCELL_ROW_116_1661 VGND VPWR sky130_fd_sc_hd__tapvpwrvgnd_1
XTAP_TAPCELL_ROW_116_1650 VGND VPWR sky130_fd_sc_hd__tapvpwrvgnd_1
XFILLER_107_11 VGND VGND VPWR VPWR sky130_fd_sc_hd__fill_2
XFILLER_1_516 VGND VGND VPWR VPWR sky130_fd_sc_hd__fill_1
XFILLER_88_100 VGND VGND VPWR VPWR sky130_fd_sc_hd__fill_1
XFILLER_89_612 VGND VGND VPWR VPWR sky130_fd_sc_hd__decap_3
XFILLER_89_623 VGND VGND VPWR VPWR sky130_fd_sc_hd__decap_3
X_7377_ _7384_/CLK _7377_/D _6657_/Y VGND VGND VPWR VPWR _7377_/Q sky130_fd_sc_hd__dfrtp_2
Xhold841 _6726_/Q VGND VGND VPWR VPWR _6726_/D sky130_fd_sc_hd__dlygate4sd3_1
Xhold852 _7061_/Q VGND VGND VPWR VPWR _7061_/D sky130_fd_sc_hd__dlygate4sd3_1
Xhold863 _7074_/Q VGND VGND VPWR VPWR _7074_/D sky130_fd_sc_hd__dlygate4sd3_1
Xmax_cap571 _3534_/Y VGND VGND VPWR VPWR _5071_/A sky130_fd_sc_hd__clkbuf_2
Xmax_cap560 _4610_/A VGND VGND VPWR VPWR _4745_/A sky130_fd_sc_hd__clkbuf_2
X_4589_ _4589_/A _4595_/B VGND VGND VPWR VPWR _7286_/D sky130_fd_sc_hd__and2_2
XFILLER_103_411 VGND VGND VPWR VPWR sky130_fd_sc_hd__fill_2
XFILLER_107_44 VGND VGND VPWR VPWR sky130_fd_sc_hd__decap_3
XFILLER_107_66 VGND VGND VPWR VPWR sky130_fd_sc_hd__decap_3
XFILLER_88_111 VGND VGND VPWR VPWR sky130_fd_sc_hd__decap_3
XFILLER_89_656 VGND VGND VPWR VPWR sky130_fd_sc_hd__decap_3
Xhold874 _7109_/Q VGND VGND VPWR VPWR _7109_/D sky130_fd_sc_hd__dlygate4sd3_1
Xhold885 _7064_/Q VGND VGND VPWR VPWR _7064_/D sky130_fd_sc_hd__dlygate4sd3_1
Xhold896 _7086_/Q VGND VGND VPWR VPWR _7086_/D sky130_fd_sc_hd__dlygate4sd3_1
X_6328_ _6675_/A VGND VGND VPWR VPWR _6328_/Y sky130_fd_sc_hd__inv_2
XFILLER_103_455 VGND VGND VPWR VPWR sky130_fd_sc_hd__decap_3
XFILLER_103_477 VGND VGND VPWR VPWR sky130_fd_sc_hd__decap_3
XFILLER_107_99 VGND VGND VPWR VPWR sky130_fd_sc_hd__decap_3
XFILLER_67_26 VGND VGND VPWR VPWR sky130_fd_sc_hd__decap_3
X_6259_ _6385_/A VGND VGND VPWR VPWR _6259_/Y sky130_fd_sc_hd__inv_2
XFILLER_103_499 VGND VGND VPWR VPWR sky130_fd_sc_hd__decap_3
XFILLER_29_211 VGND VGND VPWR VPWR sky130_fd_sc_hd__decap_3
XFILLER_76_339 VGND VGND VPWR VPWR sky130_fd_sc_hd__decap_3
XFILLER_88_177 VGND VGND VPWR VPWR sky130_fd_sc_hd__decap_3
XFILLER_57_553 VGND VGND VPWR VPWR sky130_fd_sc_hd__decap_3
XFILLER_91_309 VGND VGND VPWR VPWR sky130_fd_sc_hd__decap_3
XFILLER_44_203 VGND VGND VPWR VPWR sky130_fd_sc_hd__decap_3
XFILLER_57_564 VGND VGND VPWR VPWR sky130_fd_sc_hd__decap_3
XFILLER_72_523 VGND VGND VPWR VPWR sky130_fd_sc_hd__decap_3
XFILLER_84_350 VGND VGND VPWR VPWR sky130_fd_sc_hd__decap_3
XFILLER_84_383 VGND VGND VPWR VPWR sky130_fd_sc_hd__decap_3
XFILLER_72_589 VGND VGND VPWR VPWR sky130_fd_sc_hd__fill_2
XTAP_TAPCELL_ROW_67_1059 VGND VPWR sky130_fd_sc_hd__tapvpwrvgnd_1
XFILLER_12_100 VGND VGND VPWR VPWR sky130_fd_sc_hd__fill_2
XFILLER_13_634 VGND VGND VPWR VPWR sky130_fd_sc_hd__fill_2
XFILLER_16_85 VGND VGND VPWR VPWR sky130_fd_sc_hd__fill_1
XFILLER_52_280 VGND VGND VPWR VPWR sky130_fd_sc_hd__decap_3
XTAP_TAPCELL_ROW_80_1215 VGND VPWR sky130_fd_sc_hd__tapvpwrvgnd_1
XPHY_EDGE_ROW_11_Right_11 VGND VGND VPWR VPWR sky130_fd_sc_hd__decap_3
XFILLER_12_122 VGND VGND VPWR VPWR sky130_fd_sc_hd__decap_3
XFILLER_12_144 VGND VGND VPWR VPWR sky130_fd_sc_hd__decap_3
XFILLER_12_166 VGND VGND VPWR VPWR sky130_fd_sc_hd__decap_3
XFILLER_40_486 VGND VGND VPWR VPWR sky130_fd_sc_hd__decap_3
XFILLER_8_115 VGND VGND VPWR VPWR sky130_fd_sc_hd__decap_3
XFILLER_8_159 VGND VGND VPWR VPWR sky130_fd_sc_hd__decap_3
XTAP_TAPCELL_ROW_10_367 VGND VPWR sky130_fd_sc_hd__tapvpwrvgnd_1
XFILLER_4_321 VGND VGND VPWR VPWR sky130_fd_sc_hd__decap_3
XFILLER_4_354 VGND VGND VPWR VPWR sky130_fd_sc_hd__decap_3
XFILLER_4_365 VGND VGND VPWR VPWR sky130_fd_sc_hd__decap_3
XTAP_TAPCELL_ROW_78_1188 VGND VPWR sky130_fd_sc_hd__tapvpwrvgnd_1
XFILLER_106_282 VGND VGND VPWR VPWR sky130_fd_sc_hd__decap_3
XTAP_TAPCELL_ROW_91_1344 VGND VPWR sky130_fd_sc_hd__tapvpwrvgnd_1
XPHY_EDGE_ROW_20_Right_20 VGND VGND VPWR VPWR sky130_fd_sc_hd__decap_3
XFILLER_67_328 VGND VGND VPWR VPWR sky130_fd_sc_hd__decap_3
XFILLER_94_125 VGND VGND VPWR VPWR sky130_fd_sc_hd__decap_3
XFILLER_95_626 VGND VGND VPWR VPWR sky130_fd_sc_hd__fill_2
XFILLER_82_309 VGND VGND VPWR VPWR sky130_fd_sc_hd__decap_3
XFILLER_94_158 VGND VGND VPWR VPWR sky130_fd_sc_hd__fill_1
XFILLER_57_81 VGND VGND VPWR VPWR sky130_fd_sc_hd__decap_3
XFILLER_75_350 VGND VGND VPWR VPWR sky130_fd_sc_hd__decap_3
XFILLER_35_236 VGND VGND VPWR VPWR sky130_fd_sc_hd__decap_3
XFILLER_63_534 VGND VGND VPWR VPWR sky130_fd_sc_hd__decap_3
XFILLER_75_383 VGND VGND VPWR VPWR sky130_fd_sc_hd__decap_3
XFILLER_50_206 VGND VGND VPWR VPWR sky130_fd_sc_hd__decap_3
XFILLER_63_567 VGND VGND VPWR VPWR sky130_fd_sc_hd__decap_3
XFILLER_90_342 VGND VGND VPWR VPWR sky130_fd_sc_hd__decap_3
X_3960_ _7360_/Q _7328_/Q _4471_/S VGND VGND VPWR VPWR _7360_/D sky130_fd_sc_hd__mux2_2
XTAP_TAPCELL_ROW_18_467 VGND VPWR sky130_fd_sc_hd__tapvpwrvgnd_1
XFILLER_16_483 VGND VGND VPWR VPWR sky130_fd_sc_hd__decap_3
XFILLER_50_217 VGND VGND VPWR VPWR sky130_fd_sc_hd__decap_3
XFILLER_90_386 VGND VGND VPWR VPWR sky130_fd_sc_hd__fill_1
XTAP_TAPCELL_ROW_46_798 VGND VPWR sky130_fd_sc_hd__tapvpwrvgnd_1
X_3891_ _6951_/Q _3651_/Y _3892_/B1 _6957_/Q _3890_/X VGND VGND VPWR VPWR _3891_/X
+ sky130_fd_sc_hd__a221o_2
XFILLER_31_475 VGND VGND VPWR VPWR sky130_fd_sc_hd__decap_3
X_5630_ _5630_/A _5634_/B VGND VGND VPWR VPWR _7013_/D sky130_fd_sc_hd__and2_2
XTAP_TAPCELL_ROW_100_1451 VGND VPWR sky130_fd_sc_hd__tapvpwrvgnd_1
X_5561_ _5561_/A1 _4983_/A _4695_/X VGND VGND VPWR VPWR _7054_/D sky130_fd_sc_hd__o21a_2
X_7300_ _7364_/CLK _7300_/D _6580_/Y VGND VGND VPWR VPWR _7300_/Q sky130_fd_sc_hd__dfrtp_2
XFILLER_7_181 VGND VGND VPWR VPWR sky130_fd_sc_hd__decap_3
X_7231_ _7359_/CLK _7231_/D _6511_/Y VGND VGND VPWR VPWR _7231_/Q sky130_fd_sc_hd__dfrtp_2
X_4443_ _4778_/A _4778_/B _4795_/A _4787_/A _4779_/A VGND VGND VPWR VPWR _4761_/B
+ sky130_fd_sc_hd__a2111o_2
X_7162_ _7360_/CLK _7162_/D _6442_/Y VGND VGND VPWR VPWR _7162_/Q sky130_fd_sc_hd__dfrtp_2
X_4374_ _4371_/Y _4224_/C _4373_/Y VGND VGND VPWR VPWR _4374_/X sky130_fd_sc_hd__o21a_2
XFILLER_112_230 VGND VGND VPWR VPWR sky130_fd_sc_hd__fill_1
XFILLER_58_306 VGND VGND VPWR VPWR sky130_fd_sc_hd__fill_2
X_7093_ clkload5/A _7093_/D _6373_/Y VGND VGND VPWR VPWR _7093_/Q sky130_fd_sc_hd__dfrtp_2
X_3325_ _3323_/X _3324_/X _6983_/Q VGND VGND VPWR VPWR _3326_/B sky130_fd_sc_hd__a21oi_2
XFILLER_98_453 VGND VGND VPWR VPWR sky130_fd_sc_hd__decap_3
XFILLER_112_274 VGND VGND VPWR VPWR sky130_fd_sc_hd__decap_3
XFILLER_86_648 VGND VGND VPWR VPWR sky130_fd_sc_hd__decap_3
XTAP_TAPCELL_ROW_111_1580 VGND VPWR sky130_fd_sc_hd__tapvpwrvgnd_1
XFILLER_98_486 VGND VGND VPWR VPWR sky130_fd_sc_hd__decap_3
XFILLER_100_436 VGND VGND VPWR VPWR sky130_fd_sc_hd__decap_3
XFILLER_37_18 VGND VGND VPWR VPWR sky130_fd_sc_hd__decap_3
XFILLER_85_136 VGND VGND VPWR VPWR sky130_fd_sc_hd__decap_3
XFILLER_26_203 VGND VGND VPWR VPWR sky130_fd_sc_hd__decap_3
XFILLER_94_670 VGND VGND VPWR VPWR sky130_fd_sc_hd__fill_1
XFILLER_93_191 VGND VGND VPWR VPWR sky130_fd_sc_hd__decap_3
XFILLER_26_269 VGND VGND VPWR VPWR sky130_fd_sc_hd__decap_3
XFILLER_41_206 VGND VGND VPWR VPWR sky130_fd_sc_hd__decap_3
XFILLER_54_556 VGND VGND VPWR VPWR sky130_fd_sc_hd__decap_3
XFILLER_54_589 VGND VGND VPWR VPWR sky130_fd_sc_hd__decap_3
XFILLER_81_364 VGND VGND VPWR VPWR sky130_fd_sc_hd__fill_2
X_6946_ _6972_/CLK _6946_/D VGND VGND VPWR VPWR _6946_/Q sky130_fd_sc_hd__dfxtp_2
XFILLER_34_280 VGND VGND VPWR VPWR sky130_fd_sc_hd__decap_3
X_6877_ clkload1/A _6877_/D VGND VGND VPWR VPWR _6877_/Q sky130_fd_sc_hd__dfxtp_2
XFILLER_108_503 VGND VGND VPWR VPWR sky130_fd_sc_hd__decap_3
XFILLER_108_536 VGND VGND VPWR VPWR sky130_fd_sc_hd__decap_3
XFILLER_108_569 VGND VGND VPWR VPWR sky130_fd_sc_hd__decap_3
XFILLER_78_14 VGND VGND VPWR VPWR sky130_fd_sc_hd__decap_3
XFILLER_89_420 VGND VGND VPWR VPWR sky130_fd_sc_hd__decap_3
Xhold660 _6840_/Q VGND VGND VPWR VPWR _6840_/D sky130_fd_sc_hd__dlygate4sd3_1
Xhold671 _6930_/Q VGND VGND VPWR VPWR _6930_/D sky130_fd_sc_hd__dlygate4sd3_1
XFILLER_103_252 VGND VGND VPWR VPWR sky130_fd_sc_hd__fill_2
XFILLER_1_346 VGND VGND VPWR VPWR sky130_fd_sc_hd__decap_3
XFILLER_49_306 VGND VGND VPWR VPWR sky130_fd_sc_hd__decap_3
XFILLER_77_604 VGND VGND VPWR VPWR sky130_fd_sc_hd__decap_3
XFILLER_89_464 VGND VGND VPWR VPWR sky130_fd_sc_hd__decap_3
Xhold682 _6947_/Q VGND VGND VPWR VPWR _6947_/D sky130_fd_sc_hd__dlygate4sd3_1
Xhold693 _6766_/Q VGND VGND VPWR VPWR _6766_/D sky130_fd_sc_hd__dlygate4sd3_1
XFILLER_103_263 VGND VGND VPWR VPWR sky130_fd_sc_hd__decap_3
XFILLER_103_274 VGND VGND VPWR VPWR sky130_fd_sc_hd__decap_3
XFILLER_89_497 VGND VGND VPWR VPWR sky130_fd_sc_hd__decap_3
XFILLER_103_296 VGND VGND VPWR VPWR sky130_fd_sc_hd__decap_3
XFILLER_76_136 VGND VGND VPWR VPWR sky130_fd_sc_hd__decap_3
XFILLER_76_158 VGND VGND VPWR VPWR sky130_fd_sc_hd__decap_3
XFILLER_94_13 VGND VGND VPWR VPWR sky130_fd_sc_hd__decap_3
XFILLER_94_35 VGND VGND VPWR VPWR sky130_fd_sc_hd__decap_3
XFILLER_57_361 VGND VGND VPWR VPWR sky130_fd_sc_hd__decap_3
XFILLER_64_309 VGND VGND VPWR VPWR sky130_fd_sc_hd__decap_3
XFILLER_94_68 VGND VGND VPWR VPWR sky130_fd_sc_hd__decap_3
XFILLER_17_214 VGND VGND VPWR VPWR sky130_fd_sc_hd__decap_3
XFILLER_17_225 VGND VGND VPWR VPWR sky130_fd_sc_hd__decap_3
XFILLER_84_191 VGND VGND VPWR VPWR sky130_fd_sc_hd__decap_3
XFILLER_91_128 VGND VGND VPWR VPWR sky130_fd_sc_hd__decap_3
XFILLER_27_84 VGND VGND VPWR VPWR sky130_fd_sc_hd__decap_3
XFILLER_60_504 VGND VGND VPWR VPWR sky130_fd_sc_hd__decap_3
XFILLER_32_228 VGND VGND VPWR VPWR sky130_fd_sc_hd__decap_3
XFILLER_60_548 VGND VGND VPWR VPWR sky130_fd_sc_hd__fill_2
XFILLER_72_386 VGND VGND VPWR VPWR sky130_fd_sc_hd__decap_3
XTAP_TAPCELL_ROW_15_426 VGND VPWR sky130_fd_sc_hd__tapvpwrvgnd_1
XFILLER_13_431 VGND VGND VPWR VPWR sky130_fd_sc_hd__decap_3
XFILLER_43_50 VGND VGND VPWR VPWR sky130_fd_sc_hd__decap_3
XTAP_TAPCELL_ROW_43_768 VGND VPWR sky130_fd_sc_hd__tapvpwrvgnd_1
XTAP_TAPCELL_ROW_15_437 VGND VPWR sky130_fd_sc_hd__tapvpwrvgnd_1
XFILLER_13_475 VGND VGND VPWR VPWR sky130_fd_sc_hd__fill_1
XFILLER_40_250 VGND VGND VPWR VPWR sky130_fd_sc_hd__fill_2
XFILLER_43_83 VGND VGND VPWR VPWR sky130_fd_sc_hd__decap_3
XFILLER_9_413 VGND VGND VPWR VPWR sky130_fd_sc_hd__fill_2
XFILLER_40_283 VGND VGND VPWR VPWR sky130_fd_sc_hd__decap_3
XFILLER_40_294 VGND VGND VPWR VPWR sky130_fd_sc_hd__decap_3
XFILLER_99_217 VGND VGND VPWR VPWR sky130_fd_sc_hd__decap_3
XFILLER_114_539 VGND VGND VPWR VPWR sky130_fd_sc_hd__fill_2
XFILLER_4_173 VGND VGND VPWR VPWR sky130_fd_sc_hd__decap_3
XFILLER_99_228 VGND VGND VPWR VPWR sky130_fd_sc_hd__decap_3
XFILLER_4_66 VGND VGND VPWR VPWR sky130_fd_sc_hd__decap_3
XFILLER_4_88 VGND VGND VPWR VPWR sky130_fd_sc_hd__fill_2
XFILLER_68_615 VGND VGND VPWR VPWR sky130_fd_sc_hd__decap_3
XFILLER_68_648 VGND VGND VPWR VPWR sky130_fd_sc_hd__decap_3
XFILLER_0_390 VGND VGND VPWR VPWR sky130_fd_sc_hd__fill_2
XFILLER_67_147 VGND VGND VPWR VPWR sky130_fd_sc_hd__decap_3
XFILLER_68_91 VGND VGND VPWR VPWR sky130_fd_sc_hd__decap_3
XFILLER_95_467 VGND VGND VPWR VPWR sky130_fd_sc_hd__decap_3
X_4090_ _7302_/Q _4417_/A2 _4088_/X _4089_/X VGND VGND VPWR VPWR _4090_/X sky130_fd_sc_hd__a211o_2
XFILLER_67_169 VGND VGND VPWR VPWR sky130_fd_sc_hd__decap_3
XFILLER_63_320 VGND VGND VPWR VPWR sky130_fd_sc_hd__decap_3
XFILLER_63_364 VGND VGND VPWR VPWR sky130_fd_sc_hd__decap_3
Xplace331 _4289_/B VGND VGND VPWR VPWR _5708_/S sky130_fd_sc_hd__buf_2
Xplace320 _4422_/A2 VGND VGND VPWR VPWR _4437_/A2 sky130_fd_sc_hd__buf_2
X_6800_ _7390_/CLK _6800_/D VGND VGND VPWR VPWR _6800_/Q sky130_fd_sc_hd__dfxtp_2
XFILLER_23_206 VGND VGND VPWR VPWR sky130_fd_sc_hd__decap_3
XFILLER_23_228 VGND VGND VPWR VPWR sky130_fd_sc_hd__decap_3
XFILLER_36_589 VGND VGND VPWR VPWR sky130_fd_sc_hd__decap_3
Xplace364 _3409_/X VGND VGND VPWR VPWR _4334_/B1 sky130_fd_sc_hd__buf_2
Xplace353 _3417_/X VGND VGND VPWR VPWR _4351_/A2 sky130_fd_sc_hd__buf_2
Xplace342 _5398_/S VGND VGND VPWR VPWR _5429_/S sky130_fd_sc_hd__buf_2
X_4992_ _4987_/A _4991_/Y _5020_/A VGND VGND VPWR VPWR _4992_/Y sky130_fd_sc_hd__a21oi_2
XFILLER_16_280 VGND VGND VPWR VPWR sky130_fd_sc_hd__decap_3
Xplace386 _3429_/A VGND VGND VPWR VPWR _3392_/A sky130_fd_sc_hd__buf_2
Xplace397 _5340_/S VGND VGND VPWR VPWR _5327_/S sky130_fd_sc_hd__buf_2
Xplace375 _3818_/A2 VGND VGND VPWR VPWR _3864_/S sky130_fd_sc_hd__buf_2
X_6731_ _6965_/CLK _6731_/D VGND VGND VPWR VPWR _6731_/Q sky130_fd_sc_hd__dfxtp_2
X_3943_ _7368_/Q _7336_/Q _3943_/S VGND VGND VPWR VPWR _7368_/D sky130_fd_sc_hd__mux2_2
X_6662_ _6686_/A VGND VGND VPWR VPWR _6662_/Y sky130_fd_sc_hd__inv_2
X_3874_ _5104_/A _3874_/B VGND VGND VPWR VPWR _3874_/X sky130_fd_sc_hd__or2_2
Xclkbuf_3_2__f_clk clkbuf_0_clk/X VGND VGND VPWR VPWR clkbuf_3_2__f_clk/X sky130_fd_sc_hd__clkbuf_16
X_5613_ _5613_/A _5633_/B VGND VGND VPWR VPWR _7021_/D sky130_fd_sc_hd__or2_2
X_6593_ _6635_/A VGND VGND VPWR VPWR _6593_/Y sky130_fd_sc_hd__inv_2
XFILLER_105_539 VGND VGND VPWR VPWR sky130_fd_sc_hd__decap_3
X_7214_ _7340_/CLK _7214_/D _6494_/Y VGND VGND VPWR VPWR _7214_/Q sky130_fd_sc_hd__dfrtp_2
X_4426_ _4446_/A _4426_/B VGND VGND VPWR VPWR _4813_/A sky130_fd_sc_hd__or2_2
X_7145_ _7307_/CLK _7145_/D _6425_/Y VGND VGND VPWR VPWR _7145_/Q sky130_fd_sc_hd__dfrtp_2
XFILLER_98_250 VGND VGND VPWR VPWR sky130_fd_sc_hd__fill_2
XFILLER_100_200 VGND VGND VPWR VPWR sky130_fd_sc_hd__decap_3
XFILLER_59_615 VGND VGND VPWR VPWR sky130_fd_sc_hd__fill_1
XFILLER_86_401 VGND VGND VPWR VPWR sky130_fd_sc_hd__decap_3
X_4357_ _4352_/X _4356_/X _4327_/A VGND VGND VPWR VPWR _4367_/C sky130_fd_sc_hd__o21ai_2
XFILLER_98_283 VGND VGND VPWR VPWR sky130_fd_sc_hd__decap_3
XFILLER_100_222 VGND VGND VPWR VPWR sky130_fd_sc_hd__decap_3
XFILLER_58_136 VGND VGND VPWR VPWR sky130_fd_sc_hd__decap_3
XFILLER_58_147 VGND VGND VPWR VPWR sky130_fd_sc_hd__decap_3
XFILLER_74_607 VGND VGND VPWR VPWR sky130_fd_sc_hd__decap_3
XFILLER_86_445 VGND VGND VPWR VPWR sky130_fd_sc_hd__decap_3
X_7076_ _7364_/CLK _7076_/D _6356_/Y VGND VGND VPWR VPWR _7076_/Q sky130_fd_sc_hd__dfrtp_2
X_4288_ _4394_/A _4337_/B _4288_/C _4288_/D VGND VGND VPWR VPWR _4288_/X sky130_fd_sc_hd__or4_4
X_3308_ _3327_/A _5129_/B VGND VGND VPWR VPWR _5118_/C sky130_fd_sc_hd__nand2_2
XFILLER_104_12 VGND VGND VPWR VPWR sky130_fd_sc_hd__decap_3
XFILLER_46_309 VGND VGND VPWR VPWR sky130_fd_sc_hd__decap_3
XFILLER_67_670 VGND VGND VPWR VPWR sky130_fd_sc_hd__fill_2
XFILLER_104_56 VGND VGND VPWR VPWR sky130_fd_sc_hd__decap_3
XFILLER_39_372 VGND VGND VPWR VPWR sky130_fd_sc_hd__decap_3
XFILLER_54_320 VGND VGND VPWR VPWR sky130_fd_sc_hd__decap_3
XFILLER_54_353 VGND VGND VPWR VPWR sky130_fd_sc_hd__decap_3
XFILLER_66_191 VGND VGND VPWR VPWR sky130_fd_sc_hd__decap_3
XFILLER_14_206 VGND VGND VPWR VPWR sky130_fd_sc_hd__decap_3
XFILLER_54_397 VGND VGND VPWR VPWR sky130_fd_sc_hd__decap_3
XFILLER_81_172 VGND VGND VPWR VPWR sky130_fd_sc_hd__decap_3
XTAP_TAPCELL_ROW_64_1018 VGND VPWR sky130_fd_sc_hd__tapvpwrvgnd_1
Xfanout21 _6632_/A VGND VGND VPWR VPWR _6599_/A sky130_fd_sc_hd__buf_2
X_6929_ _6929_/CLK _6929_/D VGND VGND VPWR VPWR _6929_/Q sky130_fd_sc_hd__dfxtp_2
Xfanout32 _6606_/A VGND VGND VPWR VPWR _6604_/A sky130_fd_sc_hd__buf_2
Xfanout43 wire582/X VGND VGND VPWR VPWR _6547_/A sky130_fd_sc_hd__clkdlybuf4s25_1
Xfanout54 _6674_/A VGND VGND VPWR VPWR _6670_/A sky130_fd_sc_hd__clkdlybuf4s25_1
Xfanout65 _6619_/A VGND VGND VPWR VPWR _6647_/A sky130_fd_sc_hd__buf_2
XTAP_TAPCELL_ROW_40_727 VGND VPWR sky130_fd_sc_hd__tapvpwrvgnd_1
XFILLER_50_592 VGND VGND VPWR VPWR sky130_fd_sc_hd__fill_2
XFILLER_80_59 VGND VGND VPWR VPWR sky130_fd_sc_hd__decap_3
XFILLER_13_75 VGND VGND VPWR VPWR sky130_fd_sc_hd__fill_1
XFILLER_108_333 VGND VGND VPWR VPWR sky130_fd_sc_hd__decap_3
XFILLER_89_24 VGND VGND VPWR VPWR sky130_fd_sc_hd__decap_3
XFILLER_108_377 VGND VGND VPWR VPWR sky130_fd_sc_hd__decap_3
XFILLER_89_46 VGND VGND VPWR VPWR sky130_fd_sc_hd__decap_3
XFILLER_89_57 VGND VGND VPWR VPWR sky130_fd_sc_hd__decap_3
XTAP_TAPCELL_ROW_20_495 VGND VPWR sky130_fd_sc_hd__tapvpwrvgnd_1
XTAP_TAPCELL_ROW_75_1147 VGND VPWR sky130_fd_sc_hd__tapvpwrvgnd_1
XFILLER_104_550 VGND VGND VPWR VPWR sky130_fd_sc_hd__decap_3
XFILLER_96_209 VGND VGND VPWR VPWR sky130_fd_sc_hd__decap_3
XFILLER_104_572 VGND VGND VPWR VPWR sky130_fd_sc_hd__decap_3
XFILLER_49_103 VGND VGND VPWR VPWR sky130_fd_sc_hd__decap_3
XFILLER_77_423 VGND VGND VPWR VPWR sky130_fd_sc_hd__decap_3
XFILLER_1_187 VGND VGND VPWR VPWR sky130_fd_sc_hd__decap_3
XFILLER_49_125 VGND VGND VPWR VPWR sky130_fd_sc_hd__decap_3
XFILLER_49_158 VGND VGND VPWR VPWR sky130_fd_sc_hd__decap_3
XFILLER_49_169 VGND VGND VPWR VPWR sky130_fd_sc_hd__decap_3
XFILLER_77_478 VGND VGND VPWR VPWR sky130_fd_sc_hd__decap_3
XFILLER_92_404 VGND VGND VPWR VPWR sky130_fd_sc_hd__decap_3
XTAP_TAPCELL_ROW_48_827 VGND VPWR sky130_fd_sc_hd__tapvpwrvgnd_1
XFILLER_38_94 VGND VGND VPWR VPWR sky130_fd_sc_hd__decap_3
XFILLER_57_180 VGND VGND VPWR VPWR sky130_fd_sc_hd__decap_3
XFILLER_64_117 VGND VGND VPWR VPWR sky130_fd_sc_hd__decap_3
XFILLER_45_331 VGND VGND VPWR VPWR sky130_fd_sc_hd__decap_3
Xhold1190 _7240_/Q VGND VGND VPWR VPWR _5175_/A sky130_fd_sc_hd__dlygate4sd3_1
XFILLER_18_589 VGND VGND VPWR VPWR sky130_fd_sc_hd__decap_3
XFILLER_45_386 VGND VGND VPWR VPWR sky130_fd_sc_hd__decap_3
XFILLER_60_301 VGND VGND VPWR VPWR sky130_fd_sc_hd__decap_3
XFILLER_73_673 VGND VGND VPWR VPWR sky130_fd_sc_hd__decap_3
XTAP_TAPCELL_ROW_86_1287 VGND VPWR sky130_fd_sc_hd__tapvpwrvgnd_1
XTAP_TAPCELL_ROW_28_584 VGND VPWR sky130_fd_sc_hd__tapvpwrvgnd_1
XFILLER_60_334 VGND VGND VPWR VPWR sky130_fd_sc_hd__decap_3
XFILLER_9_243 VGND VGND VPWR VPWR sky130_fd_sc_hd__decap_3
XFILLER_70_81 VGND VGND VPWR VPWR sky130_fd_sc_hd__decap_3
Xclkload13 _6967_/CLK VGND VGND VPWR VPWR clkload13/X sky130_fd_sc_hd__clkbuf_1
Xclkload24 _7360_/CLK VGND VGND VPWR VPWR clkload24/X sky130_fd_sc_hd__clkbuf_8
Xclkload35 _7307_/CLK VGND VGND VPWR VPWR clkload35/Y sky130_fd_sc_hd__bufinv_16
X_3590_ _3590_/A _3590_/B _3590_/C VGND VGND VPWR VPWR _3620_/C sky130_fd_sc_hd__and3_2
XFILLER_114_303 VGND VGND VPWR VPWR sky130_fd_sc_hd__fill_2
X_5260_ _5260_/A0 _4964_/X _5274_/S VGND VGND VPWR VPWR _7200_/D sky130_fd_sc_hd__mux2_2
XFILLER_48_3 VGND VGND VPWR VPWR sky130_fd_sc_hd__decap_3
XFILLER_87_209 VGND VGND VPWR VPWR sky130_fd_sc_hd__decap_3
X_4211_ _4633_/A _4143_/X _4206_/X _4384_/A _4210_/X VGND VGND VPWR VPWR _4778_/A
+ sky130_fd_sc_hd__a221oi_2
XFILLER_68_401 VGND VGND VPWR VPWR sky130_fd_sc_hd__decap_3
XFILLER_68_445 VGND VGND VPWR VPWR sky130_fd_sc_hd__fill_2
XFILLER_95_220 VGND VGND VPWR VPWR sky130_fd_sc_hd__decap_3
XFILLER_95_231 VGND VGND VPWR VPWR sky130_fd_sc_hd__decap_3
X_4142_ _4205_/A _4142_/B _4142_/C VGND VGND VPWR VPWR _4142_/X sky130_fd_sc_hd__and3_2
XFILLER_28_309 VGND VGND VPWR VPWR sky130_fd_sc_hd__decap_3
XFILLER_95_264 VGND VGND VPWR VPWR sky130_fd_sc_hd__decap_3
X_4073_ _7275_/Q _4437_/A2 _4070_/X _4072_/X VGND VGND VPWR VPWR _4073_/X sky130_fd_sc_hd__a211o_2
XFILLER_83_437 VGND VGND VPWR VPWR sky130_fd_sc_hd__decap_3
XFILLER_83_459 VGND VGND VPWR VPWR sky130_fd_sc_hd__decap_3
XFILLER_36_386 VGND VGND VPWR VPWR sky130_fd_sc_hd__decap_3
XFILLER_64_684 VGND VGND VPWR VPWR sky130_fd_sc_hd__decap_3
XFILLER_51_323 VGND VGND VPWR VPWR sky130_fd_sc_hd__decap_3
XFILLER_63_194 VGND VGND VPWR VPWR sky130_fd_sc_hd__decap_3
X_4975_ _4975_/A _4975_/B VGND VGND VPWR VPWR _4975_/Y sky130_fd_sc_hd__nand2_2
XFILLER_51_389 VGND VGND VPWR VPWR sky130_fd_sc_hd__decap_3
X_6714_ _7406_/CLK _6714_/D VGND VGND VPWR VPWR _6714_/Q sky130_fd_sc_hd__dfxtp_2
X_3926_ _6913_/Q _3926_/A2 _3926_/B1 _6777_/Q _3925_/X VGND VGND VPWR VPWR _3926_/X
+ sky130_fd_sc_hd__a221o_2
XFILLER_50_29 VGND VGND VPWR VPWR sky130_fd_sc_hd__decap_3
Xclkload7 clkload7/A VGND VGND VPWR VPWR clkload7/Y sky130_fd_sc_hd__inv_4
X_6645_ _6675_/A VGND VGND VPWR VPWR _6645_/Y sky130_fd_sc_hd__inv_2
X_3857_ hold992/X _4466_/A _3856_/X VGND VGND VPWR VPWR _7387_/D sky130_fd_sc_hd__a21o_2
X_6576_ _6606_/A VGND VGND VPWR VPWR _6576_/Y sky130_fd_sc_hd__inv_2
X_3788_ _3741_/X _3785_/X _3787_/X _3735_/X VGND VGND VPWR VPWR _3788_/X sky130_fd_sc_hd__a22o_2
XFILLER_78_209 VGND VGND VPWR VPWR sky130_fd_sc_hd__decap_3
Xoutput551 _6982_/Q VGND VGND VPWR VPWR pc_out[5] sky130_fd_sc_hd__clkdlybuf4s25_1
Xoutput540 _7001_/Q VGND VGND VPWR VPWR pc_out[24] sky130_fd_sc_hd__clkdlybuf4s25_1
X_4409_ _4425_/A _4409_/B VGND VGND VPWR VPWR _4411_/B sky130_fd_sc_hd__nand2_2
XFILLER_99_581 VGND VGND VPWR VPWR sky130_fd_sc_hd__decap_3
XFILLER_101_520 VGND VGND VPWR VPWR sky130_fd_sc_hd__decap_3
XFILLER_113_391 VGND VGND VPWR VPWR sky130_fd_sc_hd__fill_1
XFILLER_115_33 VGND VGND VPWR VPWR sky130_fd_sc_hd__decap_3
XFILLER_115_55 VGND VGND VPWR VPWR sky130_fd_sc_hd__fill_1
XFILLER_59_423 VGND VGND VPWR VPWR sky130_fd_sc_hd__decap_3
X_7128_ clkload5/A _7128_/D _6408_/Y VGND VGND VPWR VPWR _7128_/Q sky130_fd_sc_hd__dfrtp_2
XFILLER_101_564 VGND VGND VPWR VPWR sky130_fd_sc_hd__decap_3
XFILLER_115_66 VGND VGND VPWR VPWR sky130_fd_sc_hd__fill_1
XFILLER_115_77 VGND VGND VPWR VPWR sky130_fd_sc_hd__decap_3
XFILLER_59_489 VGND VGND VPWR VPWR sky130_fd_sc_hd__decap_3
XFILLER_74_415 VGND VGND VPWR VPWR sky130_fd_sc_hd__decap_3
XFILLER_75_15 VGND VGND VPWR VPWR sky130_fd_sc_hd__decap_3
XFILLER_86_242 VGND VGND VPWR VPWR sky130_fd_sc_hd__decap_3
XFILLER_86_253 VGND VGND VPWR VPWR sky130_fd_sc_hd__decap_3
X_7059_ clkload5/A _7059_/D _6339_/Y VGND VGND VPWR VPWR _7059_/Q sky130_fd_sc_hd__dfrtp_2
XTAP_TAPCELL_ROW_70_1088 VGND VPWR sky130_fd_sc_hd__tapvpwrvgnd_1
XFILLER_115_99 VGND VGND VPWR VPWR sky130_fd_sc_hd__decap_3
XFILLER_46_139 VGND VGND VPWR VPWR sky130_fd_sc_hd__fill_1
XFILLER_74_437 VGND VGND VPWR VPWR sky130_fd_sc_hd__decap_3
XFILLER_27_331 VGND VGND VPWR VPWR sky130_fd_sc_hd__decap_3
XFILLER_39_191 VGND VGND VPWR VPWR sky130_fd_sc_hd__decap_3
XFILLER_27_364 VGND VGND VPWR VPWR sky130_fd_sc_hd__decap_3
XFILLER_70_610 VGND VGND VPWR VPWR sky130_fd_sc_hd__decap_3
XFILLER_15_548 VGND VGND VPWR VPWR sky130_fd_sc_hd__decap_3
XFILLER_54_183 VGND VGND VPWR VPWR sky130_fd_sc_hd__decap_3
XFILLER_54_194 VGND VGND VPWR VPWR sky130_fd_sc_hd__fill_2
XFILLER_91_25 VGND VGND VPWR VPWR sky130_fd_sc_hd__decap_3
XFILLER_24_41 VGND VGND VPWR VPWR sky130_fd_sc_hd__decap_3
XFILLER_91_69 VGND VGND VPWR VPWR sky130_fd_sc_hd__decap_3
XTAP_TAPCELL_ROW_53_885 VGND VPWR sky130_fd_sc_hd__tapvpwrvgnd_1
XTAP_TAPCELL_ROW_25_554 VGND VPWR sky130_fd_sc_hd__tapvpwrvgnd_1
XFILLER_24_85 VGND VGND VPWR VPWR sky130_fd_sc_hd__decap_3
XFILLER_10_253 VGND VGND VPWR VPWR sky130_fd_sc_hd__decap_3
XFILLER_109_620 VGND VGND VPWR VPWR sky130_fd_sc_hd__decap_3
XFILLER_10_275 VGND VGND VPWR VPWR sky130_fd_sc_hd__decap_3
XFILLER_108_141 VGND VGND VPWR VPWR sky130_fd_sc_hd__decap_3
XFILLER_40_62 VGND VGND VPWR VPWR sky130_fd_sc_hd__decap_3
XFILLER_108_185 VGND VGND VPWR VPWR sky130_fd_sc_hd__decap_3
XFILLER_97_529 VGND VGND VPWR VPWR sky130_fd_sc_hd__decap_3
XFILLER_104_391 VGND VGND VPWR VPWR sky130_fd_sc_hd__decap_3
XFILLER_49_60 VGND VGND VPWR VPWR sky130_fd_sc_hd__decap_3
XFILLER_1_23 VGND VGND VPWR VPWR sky130_fd_sc_hd__decap_3
XFILLER_37_106 VGND VGND VPWR VPWR sky130_fd_sc_hd__decap_3
XTAP_TAPCELL_ROW_88_1305 VGND VPWR sky130_fd_sc_hd__tapvpwrvgnd_1
XFILLER_37_128 VGND VGND VPWR VPWR sky130_fd_sc_hd__decap_3
XFILLER_65_426 VGND VGND VPWR VPWR sky130_fd_sc_hd__decap_3
XFILLER_92_223 VGND VGND VPWR VPWR sky130_fd_sc_hd__decap_3
XFILLER_92_267 VGND VGND VPWR VPWR sky130_fd_sc_hd__decap_3
XFILLER_33_301 VGND VGND VPWR VPWR sky130_fd_sc_hd__fill_2
XFILLER_33_312 VGND VGND VPWR VPWR sky130_fd_sc_hd__decap_3
XFILLER_45_161 VGND VGND VPWR VPWR sky130_fd_sc_hd__decap_3
XFILLER_65_92 VGND VGND VPWR VPWR sky130_fd_sc_hd__decap_3
XFILLER_73_481 VGND VGND VPWR VPWR sky130_fd_sc_hd__decap_3
XFILLER_33_367 VGND VGND VPWR VPWR sky130_fd_sc_hd__fill_1
XFILLER_61_665 VGND VGND VPWR VPWR sky130_fd_sc_hd__decap_3
XFILLER_33_389 VGND VGND VPWR VPWR sky130_fd_sc_hd__decap_3
XFILLER_60_197 VGND VGND VPWR VPWR sky130_fd_sc_hd__decap_3
X_4760_ _4983_/A _4760_/B VGND VGND VPWR VPWR _4760_/Y sky130_fd_sc_hd__nand2_2
XFILLER_81_91 VGND VGND VPWR VPWR sky130_fd_sc_hd__decap_3
X_4691_ _7004_/Q _4665_/X _4804_/A _4757_/A VGND VGND VPWR VPWR _4749_/B sky130_fd_sc_hd__a31o_2
X_3711_ _3746_/A VGND VGND VPWR VPWR _3735_/A sky130_fd_sc_hd__inv_2
XTAP_TAPCELL_ROW_99_1445 VGND VPWR sky130_fd_sc_hd__tapvpwrvgnd_1
XTAP_TAPCELL_ROW_99_1434 VGND VPWR sky130_fd_sc_hd__tapvpwrvgnd_1
XPHY_EDGE_ROW_112_Right_112 VGND VGND VPWR VPWR sky130_fd_sc_hd__decap_3
X_6430_ _6462_/A VGND VGND VPWR VPWR _6430_/Y sky130_fd_sc_hd__inv_2
X_3642_ _6718_/Q _6808_/Q _6896_/Q _6944_/Q _3991_/B _3665_/B VGND VGND VPWR VPWR
+ _3642_/X sky130_fd_sc_hd__mux4_2
X_6361_ _6385_/A VGND VGND VPWR VPWR _6361_/Y sky130_fd_sc_hd__inv_2
X_5312_ _7174_/Q _4864_/X _5325_/S VGND VGND VPWR VPWR _7174_/D sky130_fd_sc_hd__mux2_2
X_3573_ _7316_/Q _3994_/S _4532_/S _7284_/Q VGND VGND VPWR VPWR _3573_/X sky130_fd_sc_hd__a22o_2
XPHY_EDGE_ROW_49_Right_49 VGND VGND VPWR VPWR sky130_fd_sc_hd__decap_3
XFILLER_114_144 VGND VGND VPWR VPWR sky130_fd_sc_hd__decap_3
XFILLER_5_290 VGND VGND VPWR VPWR sky130_fd_sc_hd__decap_3
XFILLER_88_507 VGND VGND VPWR VPWR sky130_fd_sc_hd__decap_3
X_6292_ _6637_/A VGND VGND VPWR VPWR _6292_/Y sky130_fd_sc_hd__inv_2
XFILLER_102_306 VGND VGND VPWR VPWR sky130_fd_sc_hd__fill_2
X_5243_ _5243_/A0 _4822_/X _5262_/S VGND VGND VPWR VPWR _7208_/D sky130_fd_sc_hd__mux2_2
XFILLER_102_339 VGND VGND VPWR VPWR sky130_fd_sc_hd__decap_3
XFILLER_96_551 VGND VGND VPWR VPWR sky130_fd_sc_hd__decap_3
X_4125_ _4205_/A _4117_/B _4117_/C _4124_/B VGND VGND VPWR VPWR _4125_/X sky130_fd_sc_hd__a31o_2
XFILLER_110_361 VGND VGND VPWR VPWR sky130_fd_sc_hd__decap_3
XFILLER_110_383 VGND VGND VPWR VPWR sky130_fd_sc_hd__decap_3
XFILLER_28_128 VGND VGND VPWR VPWR sky130_fd_sc_hd__decap_3
XFILLER_56_437 VGND VGND VPWR VPWR sky130_fd_sc_hd__decap_3
XFILLER_68_297 VGND VGND VPWR VPWR sky130_fd_sc_hd__decap_3
XFILLER_83_223 VGND VGND VPWR VPWR sky130_fd_sc_hd__fill_1
XFILLER_83_234 VGND VGND VPWR VPWR sky130_fd_sc_hd__decap_3
X_4056_ _7340_/Q _3943_/S _5229_/C _7148_/Q VGND VGND VPWR VPWR _4056_/X sky130_fd_sc_hd__a22o_2
XPHY_EDGE_ROW_58_Right_58 VGND VGND VPWR VPWR sky130_fd_sc_hd__decap_3
XFILLER_36_161 VGND VGND VPWR VPWR sky130_fd_sc_hd__decap_3
XFILLER_37_673 VGND VGND VPWR VPWR sky130_fd_sc_hd__fill_2
XFILLER_43_109 VGND VGND VPWR VPWR sky130_fd_sc_hd__decap_3
XFILLER_83_278 VGND VGND VPWR VPWR sky130_fd_sc_hd__fill_2
XTAP_TAPCELL_ROW_108_1552 VGND VPWR sky130_fd_sc_hd__tapvpwrvgnd_1
XFILLER_24_312 VGND VGND VPWR VPWR sky130_fd_sc_hd__decap_3
XFILLER_24_334 VGND VGND VPWR VPWR sky130_fd_sc_hd__decap_3
XFILLER_36_194 VGND VGND VPWR VPWR sky130_fd_sc_hd__fill_2
XFILLER_52_632 VGND VGND VPWR VPWR sky130_fd_sc_hd__decap_3
XFILLER_101_46 VGND VGND VPWR VPWR sky130_fd_sc_hd__decap_3
XFILLER_101_57 VGND VGND VPWR VPWR sky130_fd_sc_hd__decap_3
XFILLER_51_142 VGND VGND VPWR VPWR sky130_fd_sc_hd__decap_3
XFILLER_51_197 VGND VGND VPWR VPWR sky130_fd_sc_hd__decap_3
XFILLER_61_39 VGND VGND VPWR VPWR sky130_fd_sc_hd__decap_3
X_4958_ _4983_/B VGND VGND VPWR VPWR _4958_/Y sky130_fd_sc_hd__inv_2
XTAP_TAPCELL_ROW_22_513 VGND VPWR sky130_fd_sc_hd__tapvpwrvgnd_1
X_4889_ _4890_/B _4889_/B VGND VGND VPWR VPWR _4889_/Y sky130_fd_sc_hd__xnor2_2
X_3909_ hold956/X _5104_/A _3908_/X VGND VGND VPWR VPWR _7379_/D sky130_fd_sc_hd__a21o_2
XTAP_TAPCELL_ROW_50_855 VGND VPWR sky130_fd_sc_hd__tapvpwrvgnd_1
X_6628_ _6635_/A VGND VGND VPWR VPWR _6628_/Y sky130_fd_sc_hd__inv_2
XPHY_EDGE_ROW_67_Right_67 VGND VGND VPWR VPWR sky130_fd_sc_hd__decap_3
XFILLER_106_612 VGND VGND VPWR VPWR sky130_fd_sc_hd__decap_3
XFILLER_3_216 VGND VGND VPWR VPWR sky130_fd_sc_hd__decap_3
X_6559_ _6637_/A VGND VGND VPWR VPWR _6559_/Y sky130_fd_sc_hd__inv_2
XFILLER_105_122 VGND VGND VPWR VPWR sky130_fd_sc_hd__decap_3
XFILLER_105_133 VGND VGND VPWR VPWR sky130_fd_sc_hd__decap_3
XFILLER_106_645 VGND VGND VPWR VPWR sky130_fd_sc_hd__decap_3
XFILLER_10_43 VGND VGND VPWR VPWR sky130_fd_sc_hd__decap_3
XFILLER_105_166 VGND VGND VPWR VPWR sky130_fd_sc_hd__fill_2
XTAP_TAPCELL_ROW_72_1117 VGND VPWR sky130_fd_sc_hd__tapvpwrvgnd_1
XFILLER_105_199 VGND VGND VPWR VPWR sky130_fd_sc_hd__decap_3
XFILLER_10_98 VGND VGND VPWR VPWR sky130_fd_sc_hd__fill_1
XFILLER_86_47 VGND VGND VPWR VPWR sky130_fd_sc_hd__decap_3
XFILLER_87_573 VGND VGND VPWR VPWR sky130_fd_sc_hd__decap_3
XFILLER_101_372 VGND VGND VPWR VPWR sky130_fd_sc_hd__decap_3
XFILLER_19_106 VGND VGND VPWR VPWR sky130_fd_sc_hd__decap_3
XFILLER_19_52 VGND VGND VPWR VPWR sky130_fd_sc_hd__decap_3
XFILLER_19_63 VGND VGND VPWR VPWR sky130_fd_sc_hd__decap_3
XFILLER_19_74 VGND VGND VPWR VPWR sky130_fd_sc_hd__decap_3
XFILLER_47_426 VGND VGND VPWR VPWR sky130_fd_sc_hd__decap_3
XFILLER_59_275 VGND VGND VPWR VPWR sky130_fd_sc_hd__decap_3
XFILLER_74_212 VGND VGND VPWR VPWR sky130_fd_sc_hd__decap_3
XPHY_EDGE_ROW_76_Right_76 VGND VGND VPWR VPWR sky130_fd_sc_hd__decap_3
XFILLER_74_245 VGND VGND VPWR VPWR sky130_fd_sc_hd__decap_3
XTAP_TAPCELL_ROW_58_944 VGND VPWR sky130_fd_sc_hd__tapvpwrvgnd_1
XFILLER_27_161 VGND VGND VPWR VPWR sky130_fd_sc_hd__decap_3
XFILLER_55_470 VGND VGND VPWR VPWR sky130_fd_sc_hd__decap_3
XTAP_TAPCELL_ROW_2_271 VGND VPWR sky130_fd_sc_hd__tapvpwrvgnd_1
XFILLER_15_334 VGND VGND VPWR VPWR sky130_fd_sc_hd__fill_2
XFILLER_27_172 VGND VGND VPWR VPWR sky130_fd_sc_hd__decap_3
XFILLER_15_367 VGND VGND VPWR VPWR sky130_fd_sc_hd__fill_2
XFILLER_15_378 VGND VGND VPWR VPWR sky130_fd_sc_hd__fill_2
XFILLER_30_304 VGND VGND VPWR VPWR sky130_fd_sc_hd__decap_3
XFILLER_35_73 VGND VGND VPWR VPWR sky130_fd_sc_hd__decap_3
XFILLER_35_84 VGND VGND VPWR VPWR sky130_fd_sc_hd__decap_3
XFILLER_70_462 VGND VGND VPWR VPWR sky130_fd_sc_hd__decap_3
XTAP_TAPCELL_ROW_83_1246 VGND VPWR sky130_fd_sc_hd__tapvpwrvgnd_1
XFILLER_42_175 VGND VGND VPWR VPWR sky130_fd_sc_hd__decap_3
XFILLER_70_495 VGND VGND VPWR VPWR sky130_fd_sc_hd__decap_3
XFILLER_30_359 VGND VGND VPWR VPWR sky130_fd_sc_hd__decap_3
XFILLER_51_50 VGND VGND VPWR VPWR sky130_fd_sc_hd__decap_3
XFILLER_51_72 VGND VGND VPWR VPWR sky130_fd_sc_hd__decap_3
XFILLER_7_522 VGND VGND VPWR VPWR sky130_fd_sc_hd__fill_1
XPHY_EDGE_ROW_85_Right_85 VGND VGND VPWR VPWR sky130_fd_sc_hd__decap_3
XTAP_TAPCELL_ROW_94_1375 VGND VPWR sky130_fd_sc_hd__tapvpwrvgnd_1
XFILLER_111_125 VGND VGND VPWR VPWR sky130_fd_sc_hd__fill_2
XFILLER_112_648 VGND VGND VPWR VPWR sky130_fd_sc_hd__decap_3
XFILLER_32_6 VGND VGND VPWR VPWR sky130_fd_sc_hd__decap_3
XFILLER_97_337 VGND VGND VPWR VPWR sky130_fd_sc_hd__decap_3
XPHY_EDGE_ROW_29_Left_146 VGND VGND VPWR VPWR sky130_fd_sc_hd__decap_3
XFILLER_111_169 VGND VGND VPWR VPWR sky130_fd_sc_hd__fill_2
XPHY_EDGE_ROW_94_Right_94 VGND VGND VPWR VPWR sky130_fd_sc_hd__decap_3
XFILLER_38_437 VGND VGND VPWR VPWR sky130_fd_sc_hd__decap_3
XFILLER_65_223 VGND VGND VPWR VPWR sky130_fd_sc_hd__fill_1
XFILLER_78_595 VGND VGND VPWR VPWR sky130_fd_sc_hd__decap_3
XFILLER_65_234 VGND VGND VPWR VPWR sky130_fd_sc_hd__decap_3
XFILLER_65_245 VGND VGND VPWR VPWR sky130_fd_sc_hd__decap_3
XFILLER_76_80 VGND VGND VPWR VPWR sky130_fd_sc_hd__fill_1
XFILLER_19_673 VGND VGND VPWR VPWR sky130_fd_sc_hd__fill_1
XFILLER_53_429 VGND VGND VPWR VPWR sky130_fd_sc_hd__decap_3
XFILLER_65_278 VGND VGND VPWR VPWR sky130_fd_sc_hd__fill_2
XFILLER_18_172 VGND VGND VPWR VPWR sky130_fd_sc_hd__decap_3
XFILLER_80_237 VGND VGND VPWR VPWR sky130_fd_sc_hd__decap_3
XFILLER_33_153 VGND VGND VPWR VPWR sky130_fd_sc_hd__decap_3
XFILLER_80_259 VGND VGND VPWR VPWR sky130_fd_sc_hd__decap_3
XFILLER_21_304 VGND VGND VPWR VPWR sky130_fd_sc_hd__decap_3
XFILLER_21_337 VGND VGND VPWR VPWR sky130_fd_sc_hd__decap_3
XFILLER_33_175 VGND VGND VPWR VPWR sky130_fd_sc_hd__decap_3
XFILLER_61_473 VGND VGND VPWR VPWR sky130_fd_sc_hd__fill_1
X_4812_ _4827_/A _4827_/B VGND VGND VPWR VPWR _4812_/Y sky130_fd_sc_hd__nor2_2
XPHY_EDGE_ROW_38_Left_155 VGND VGND VPWR VPWR sky130_fd_sc_hd__decap_3
X_4743_ _4745_/A _4081_/X _4741_/X _4742_/Y VGND VGND VPWR VPWR _4743_/X sky130_fd_sc_hd__a31o_2
XTAP_TAPCELL_ROW_103_1493 VGND VPWR sky130_fd_sc_hd__tapvpwrvgnd_1
XTAP_TAPCELL_ROW_103_1482 VGND VPWR sky130_fd_sc_hd__tapvpwrvgnd_1
X_6413_ _6604_/A VGND VGND VPWR VPWR _6413_/Y sky130_fd_sc_hd__inv_2
X_4674_ _6989_/Q _4677_/B VGND VGND VPWR VPWR _4674_/X sky130_fd_sc_hd__or2_2
X_7393_ _7393_/CLK _7393_/D _6673_/Y VGND VGND VPWR VPWR _7393_/Q sky130_fd_sc_hd__dfrtp_2
X_3625_ _3618_/X _3619_/Y _3620_/X _3624_/X VGND VGND VPWR VPWR _3625_/X sky130_fd_sc_hd__a31o_2
XFILLER_115_420 VGND VGND VPWR VPWR sky130_fd_sc_hd__decap_3
X_6344_ _6347_/A VGND VGND VPWR VPWR _6344_/Y sky130_fd_sc_hd__inv_2
X_3556_ _3556_/A _3556_/B _3556_/C VGND VGND VPWR VPWR _3556_/X sky130_fd_sc_hd__or3_2
XFILLER_103_604 VGND VGND VPWR VPWR sky130_fd_sc_hd__decap_3
XFILLER_103_626 VGND VGND VPWR VPWR sky130_fd_sc_hd__decap_3
XFILLER_88_315 VGND VGND VPWR VPWR sky130_fd_sc_hd__decap_3
X_6275_ _6275_/A VGND VGND VPWR VPWR _6275_/Y sky130_fd_sc_hd__inv_2
XPHY_EDGE_ROW_47_Left_164 VGND VGND VPWR VPWR sky130_fd_sc_hd__decap_3
XFILLER_102_103 VGND VGND VPWR VPWR sky130_fd_sc_hd__decap_3
XFILLER_88_359 VGND VGND VPWR VPWR sky130_fd_sc_hd__decap_3
X_3487_ _3469_/A _3469_/B _3449_/A _7247_/Q _3365_/A VGND VGND VPWR VPWR _3487_/X
+ sky130_fd_sc_hd__o2111a_2
XFILLER_102_158 VGND VGND VPWR VPWR sky130_fd_sc_hd__decap_3
XFILLER_29_437 VGND VGND VPWR VPWR sky130_fd_sc_hd__fill_2
XFILLER_56_212 VGND VGND VPWR VPWR sky130_fd_sc_hd__decap_3
XFILLER_84_510 VGND VGND VPWR VPWR sky130_fd_sc_hd__decap_3
X_5157_ _5157_/A0 _5156_/X _5159_/S VGND VGND VPWR VPWR _7248_/D sky130_fd_sc_hd__mux2_2
XFILLER_56_245 VGND VGND VPWR VPWR sky130_fd_sc_hd__decap_3
XFILLER_56_256 VGND VGND VPWR VPWR sky130_fd_sc_hd__decap_3
XFILLER_84_554 VGND VGND VPWR VPWR sky130_fd_sc_hd__fill_1
X_5088_ _5086_/A _4365_/X _5086_/X _5087_/Y _5020_/A VGND VGND VPWR VPWR _5088_/X
+ sky130_fd_sc_hd__a2111o_2
X_4108_ _4394_/A _4394_/B _4107_/X VGND VGND VPWR VPWR _4142_/C sky130_fd_sc_hd__or3b_2
XFILLER_44_418 VGND VGND VPWR VPWR sky130_fd_sc_hd__fill_2
XFILLER_56_289 VGND VGND VPWR VPWR sky130_fd_sc_hd__decap_3
XFILLER_84_598 VGND VGND VPWR VPWR sky130_fd_sc_hd__decap_3
X_4039_ _4039_/A _4458_/A VGND VGND VPWR VPWR _4040_/B sky130_fd_sc_hd__and2_2
XTAP_TAPCELL_ROW_55_914 VGND VPWR sky130_fd_sc_hd__tapvpwrvgnd_1
XFILLER_112_56 VGND VGND VPWR VPWR sky130_fd_sc_hd__decap_3
XFILLER_37_492 VGND VGND VPWR VPWR sky130_fd_sc_hd__decap_3
XFILLER_71_237 VGND VGND VPWR VPWR sky130_fd_sc_hd__decap_3
XFILLER_24_131 VGND VGND VPWR VPWR sky130_fd_sc_hd__decap_3
XFILLER_24_153 VGND VGND VPWR VPWR sky130_fd_sc_hd__decap_3
XFILLER_72_27 VGND VGND VPWR VPWR sky130_fd_sc_hd__fill_1
XFILLER_72_38 VGND VGND VPWR VPWR sky130_fd_sc_hd__decap_3
XPHY_EDGE_ROW_56_Left_173 VGND VGND VPWR VPWR sky130_fd_sc_hd__decap_3
XFILLER_12_304 VGND VGND VPWR VPWR sky130_fd_sc_hd__decap_3
XFILLER_12_315 VGND VGND VPWR VPWR sky130_fd_sc_hd__decap_3
XFILLER_24_186 VGND VGND VPWR VPWR sky130_fd_sc_hd__decap_3
XTAP_TAPCELL_ROW_35_671 VGND VPWR sky130_fd_sc_hd__tapvpwrvgnd_1
XFILLER_24_197 VGND VGND VPWR VPWR sky130_fd_sc_hd__decap_3
XFILLER_40_657 VGND VGND VPWR VPWR sky130_fd_sc_hd__decap_3
XFILLER_115_3 VGND VGND VPWR VPWR sky130_fd_sc_hd__fill_2
XFILLER_106_442 VGND VGND VPWR VPWR sky130_fd_sc_hd__decap_3
XFILLER_21_86 VGND VGND VPWR VPWR sky130_fd_sc_hd__decap_3
XPHY_EDGE_ROW_65_Left_182 VGND VGND VPWR VPWR sky130_fd_sc_hd__decap_3
XFILLER_97_24 VGND VGND VPWR VPWR sky130_fd_sc_hd__decap_3
XFILLER_79_337 VGND VGND VPWR VPWR sky130_fd_sc_hd__decap_3
XFILLER_97_57 VGND VGND VPWR VPWR sky130_fd_sc_hd__decap_3
XTAP_TAPCELL_ROW_7_341 VGND VPWR sky130_fd_sc_hd__tapvpwrvgnd_1
XTAP_TAPCELL_ROW_7_330 VGND VPWR sky130_fd_sc_hd__tapvpwrvgnd_1
XFILLER_87_370 VGND VGND VPWR VPWR sky130_fd_sc_hd__decap_3
XFILLER_94_318 VGND VGND VPWR VPWR sky130_fd_sc_hd__decap_3
XFILLER_47_234 VGND VGND VPWR VPWR sky130_fd_sc_hd__decap_3
XFILLER_75_543 VGND VGND VPWR VPWR sky130_fd_sc_hd__decap_3
XFILLER_47_267 VGND VGND VPWR VPWR sky130_fd_sc_hd__fill_1
XFILLER_47_289 VGND VGND VPWR VPWR sky130_fd_sc_hd__decap_3
XFILLER_62_204 VGND VGND VPWR VPWR sky130_fd_sc_hd__decap_3
XFILLER_75_576 VGND VGND VPWR VPWR sky130_fd_sc_hd__decap_3
XPHY_EDGE_ROW_74_Left_191 VGND VGND VPWR VPWR sky130_fd_sc_hd__decap_3
XFILLER_16_610 VGND VGND VPWR VPWR sky130_fd_sc_hd__decap_3
XFILLER_16_643 VGND VGND VPWR VPWR sky130_fd_sc_hd__fill_1
XFILLER_28_470 VGND VGND VPWR VPWR sky130_fd_sc_hd__decap_3
XFILLER_62_237 VGND VGND VPWR VPWR sky130_fd_sc_hd__decap_3
XFILLER_15_153 VGND VGND VPWR VPWR sky130_fd_sc_hd__decap_3
XFILLER_90_568 VGND VGND VPWR VPWR sky130_fd_sc_hd__decap_3
XFILLER_15_175 VGND VGND VPWR VPWR sky130_fd_sc_hd__decap_3
XFILLER_43_495 VGND VGND VPWR VPWR sky130_fd_sc_hd__decap_3
XFILLER_30_123 VGND VGND VPWR VPWR sky130_fd_sc_hd__decap_3
XFILLER_31_646 VGND VGND VPWR VPWR sky130_fd_sc_hd__fill_1
XFILLER_30_156 VGND VGND VPWR VPWR sky130_fd_sc_hd__decap_3
XFILLER_11_370 VGND VGND VPWR VPWR sky130_fd_sc_hd__fill_1
XFILLER_30_189 VGND VGND VPWR VPWR sky130_fd_sc_hd__decap_3
XTAP_TAPCELL_ROW_96_1404 VGND VPWR sky130_fd_sc_hd__tapvpwrvgnd_1
XFILLER_116_206 VGND VGND VPWR VPWR sky130_fd_sc_hd__fill_2
XFILLER_116_228 VGND VGND VPWR VPWR sky130_fd_sc_hd__decap_3
XFILLER_7_352 VGND VGND VPWR VPWR sky130_fd_sc_hd__decap_3
XFILLER_7_66 VGND VGND VPWR VPWR sky130_fd_sc_hd__decap_3
X_4390_ _7241_/Q _4433_/B _3945_/S _7209_/Q VGND VGND VPWR VPWR _4390_/X sky130_fd_sc_hd__a22o_2
X_3410_ _7219_/Q _4307_/A2 _4532_/S _7032_/Q VGND VGND VPWR VPWR _3410_/X sky130_fd_sc_hd__a22o_2
XFILLER_112_401 VGND VGND VPWR VPWR sky130_fd_sc_hd__decap_3
X_3341_ _3341_/A VGND VGND VPWR VPWR _5642_/A sky130_fd_sc_hd__inv_2
XFILLER_98_602 VGND VGND VPWR VPWR sky130_fd_sc_hd__decap_3
XFILLER_97_134 VGND VGND VPWR VPWR sky130_fd_sc_hd__decap_3
XFILLER_30_3 VGND VGND VPWR VPWR sky130_fd_sc_hd__decap_3
XFILLER_112_489 VGND VGND VPWR VPWR sky130_fd_sc_hd__fill_1
XFILLER_66_510 VGND VGND VPWR VPWR sky130_fd_sc_hd__decap_3
XFILLER_87_90 VGND VGND VPWR VPWR sky130_fd_sc_hd__decap_3
XFILLER_97_178 VGND VGND VPWR VPWR sky130_fd_sc_hd__decap_3
Xhold1008 _7184_/Q VGND VGND VPWR VPWR _5290_/A0 sky130_fd_sc_hd__dlygate4sd3_1
Xhold1019 _7376_/Q VGND VGND VPWR VPWR _3924_/A1 sky130_fd_sc_hd__dlygate4sd3_1
X_5011_ _4836_/S _6991_/D _5010_/X VGND VGND VPWR VPWR _5011_/X sky130_fd_sc_hd__o21a_2
XFILLER_38_245 VGND VGND VPWR VPWR sky130_fd_sc_hd__decap_3
XFILLER_78_392 VGND VGND VPWR VPWR sky130_fd_sc_hd__decap_3
XFILLER_93_340 VGND VGND VPWR VPWR sky130_fd_sc_hd__decap_3
XFILLER_26_407 VGND VGND VPWR VPWR sky130_fd_sc_hd__decap_3
XFILLER_38_256 VGND VGND VPWR VPWR sky130_fd_sc_hd__decap_3
XFILLER_93_373 VGND VGND VPWR VPWR sky130_fd_sc_hd__decap_3
XFILLER_53_237 VGND VGND VPWR VPWR sky130_fd_sc_hd__fill_1
XFILLER_81_535 VGND VGND VPWR VPWR sky130_fd_sc_hd__decap_3
X_6962_ _6968_/CLK _6962_/D VGND VGND VPWR VPWR _6962_/Q sky130_fd_sc_hd__dfxtp_2
XTAP_TAPCELL_ROW_105_1511 VGND VPWR sky130_fd_sc_hd__tapvpwrvgnd_1
X_6893_ _7404_/CLK _6893_/D VGND VGND VPWR VPWR _6893_/Q sky130_fd_sc_hd__dfxtp_2
XFILLER_21_101 VGND VGND VPWR VPWR sky130_fd_sc_hd__decap_3
XFILLER_21_145 VGND VGND VPWR VPWR sky130_fd_sc_hd__decap_3
XFILLER_61_281 VGND VGND VPWR VPWR sky130_fd_sc_hd__fill_1
XTAP_TAPCELL_ROW_32_641 VGND VPWR sky130_fd_sc_hd__tapvpwrvgnd_1
XTAP_TAPCELL_ROW_32_630 VGND VPWR sky130_fd_sc_hd__tapvpwrvgnd_1
XFILLER_21_167 VGND VGND VPWR VPWR sky130_fd_sc_hd__fill_1
XFILLER_21_178 VGND VGND VPWR VPWR sky130_fd_sc_hd__decap_3
XTAP_TAPCELL_ROW_60_972 VGND VPWR sky130_fd_sc_hd__tapvpwrvgnd_1
X_4726_ _3757_/S _5655_/A _3670_/X _4467_/B VGND VGND VPWR VPWR _4726_/X sky130_fd_sc_hd__o211a_2
XFILLER_107_217 VGND VGND VPWR VPWR sky130_fd_sc_hd__decap_3
XFILLER_107_228 VGND VGND VPWR VPWR sky130_fd_sc_hd__decap_3
X_4657_ _4720_/A _4655_/X _4948_/A VGND VGND VPWR VPWR _4658_/B sky130_fd_sc_hd__a21oi_2
X_7376_ _7383_/CLK _7376_/D _6656_/Y VGND VGND VPWR VPWR _7376_/Q sky130_fd_sc_hd__dfrtp_2
Xhold820 _6755_/Q VGND VGND VPWR VPWR _6755_/D sky130_fd_sc_hd__dlygate4sd3_1
XTAP_TAPCELL_ROW_116_1651 VGND VPWR sky130_fd_sc_hd__tapvpwrvgnd_1
XTAP_TAPCELL_ROW_116_1640 VGND VPWR sky130_fd_sc_hd__tapvpwrvgnd_1
XFILLER_107_23 VGND VGND VPWR VPWR sky130_fd_sc_hd__decap_3
Xhold831 _6915_/Q VGND VGND VPWR VPWR _6915_/D sky130_fd_sc_hd__dlygate4sd3_1
Xhold842 _6769_/Q VGND VGND VPWR VPWR _6769_/D sky130_fd_sc_hd__dlygate4sd3_1
Xhold853 _7055_/Q VGND VGND VPWR VPWR _7055_/D sky130_fd_sc_hd__dlygate4sd3_1
Xhold864 _7097_/Q VGND VGND VPWR VPWR _7097_/D sky130_fd_sc_hd__dlygate4sd3_1
Xmax_cap572 _3339_/Y VGND VGND VPWR VPWR _3469_/A sky130_fd_sc_hd__clkbuf_2
Xmax_cap561 _4619_/Y VGND VGND VPWR VPWR _4625_/A2 sky130_fd_sc_hd__buf_1
X_6327_ _6675_/A VGND VGND VPWR VPWR _6327_/Y sky130_fd_sc_hd__inv_2
XFILLER_103_434 VGND VGND VPWR VPWR sky130_fd_sc_hd__decap_3
XFILLER_88_123 VGND VGND VPWR VPWR sky130_fd_sc_hd__decap_3
XFILLER_89_635 VGND VGND VPWR VPWR sky130_fd_sc_hd__decap_3
Xhold875 _7112_/Q VGND VGND VPWR VPWR _7112_/D sky130_fd_sc_hd__dlygate4sd3_1
Xhold886 _7078_/Q VGND VGND VPWR VPWR _7078_/D sky130_fd_sc_hd__dlygate4sd3_1
Xhold897 _7059_/Q VGND VGND VPWR VPWR _7059_/D sky130_fd_sc_hd__dlygate4sd3_1
X_3539_ _3544_/A _3544_/B VGND VGND VPWR VPWR _3547_/A sky130_fd_sc_hd__nand2_2
XFILLER_107_78 VGND VGND VPWR VPWR sky130_fd_sc_hd__fill_2
XFILLER_88_156 VGND VGND VPWR VPWR sky130_fd_sc_hd__decap_3
XFILLER_89_668 VGND VGND VPWR VPWR sky130_fd_sc_hd__decap_3
XFILLER_89_679 VGND VGND VPWR VPWR sky130_fd_sc_hd__decap_3
XTAP_TAPCELL_ROW_4_300 VGND VPWR sky130_fd_sc_hd__tapvpwrvgnd_1
XFILLER_69_381 VGND VGND VPWR VPWR sky130_fd_sc_hd__decap_3
X_5209_ _5209_/A _5217_/B VGND VGND VPWR VPWR _7224_/D sky130_fd_sc_hd__and2_2
XFILLER_29_234 VGND VGND VPWR VPWR sky130_fd_sc_hd__decap_3
XFILLER_29_245 VGND VGND VPWR VPWR sky130_fd_sc_hd__decap_3
XFILLER_83_26 VGND VGND VPWR VPWR sky130_fd_sc_hd__decap_3
XFILLER_84_362 VGND VGND VPWR VPWR sky130_fd_sc_hd__fill_2
XFILLER_44_215 VGND VGND VPWR VPWR sky130_fd_sc_hd__decap_3
XFILLER_44_259 VGND VGND VPWR VPWR sky130_fd_sc_hd__decap_3
XFILLER_72_579 VGND VGND VPWR VPWR sky130_fd_sc_hd__fill_1
XFILLER_16_75 VGND VGND VPWR VPWR sky130_fd_sc_hd__decap_3
XFILLER_25_473 VGND VGND VPWR VPWR sky130_fd_sc_hd__decap_3
XTAP_TAPCELL_ROW_80_1216 VGND VPWR sky130_fd_sc_hd__tapvpwrvgnd_1
XFILLER_40_421 VGND VGND VPWR VPWR sky130_fd_sc_hd__decap_3
XFILLER_12_156 VGND VGND VPWR VPWR sky130_fd_sc_hd__fill_2
XFILLER_12_178 VGND VGND VPWR VPWR sky130_fd_sc_hd__fill_1
XFILLER_12_189 VGND VGND VPWR VPWR sky130_fd_sc_hd__decap_3
XFILLER_40_498 VGND VGND VPWR VPWR sky130_fd_sc_hd__decap_3
XFILLER_32_85 VGND VGND VPWR VPWR sky130_fd_sc_hd__decap_3
XFILLER_4_300 VGND VGND VPWR VPWR sky130_fd_sc_hd__fill_2
XTAP_TAPCELL_ROW_10_368 VGND VPWR sky130_fd_sc_hd__tapvpwrvgnd_1
XFILLER_4_333 VGND VGND VPWR VPWR sky130_fd_sc_hd__decap_3
XTAP_TAPCELL_ROW_78_1189 VGND VPWR sky130_fd_sc_hd__tapvpwrvgnd_1
XFILLER_106_294 VGND VGND VPWR VPWR sky130_fd_sc_hd__decap_3
XFILLER_4_377 VGND VGND VPWR VPWR sky130_fd_sc_hd__decap_3
XFILLER_79_101 VGND VGND VPWR VPWR sky130_fd_sc_hd__decap_3
XTAP_TAPCELL_ROW_91_1345 VGND VPWR sky130_fd_sc_hd__tapvpwrvgnd_1
XFILLER_79_134 VGND VGND VPWR VPWR sky130_fd_sc_hd__decap_3
XFILLER_0_561 VGND VGND VPWR VPWR sky130_fd_sc_hd__decap_3
XFILLER_79_167 VGND VGND VPWR VPWR sky130_fd_sc_hd__fill_1
XFILLER_79_178 VGND VGND VPWR VPWR sky130_fd_sc_hd__fill_1
XFILLER_57_60 VGND VGND VPWR VPWR sky130_fd_sc_hd__decap_3
XFILLER_35_204 VGND VGND VPWR VPWR sky130_fd_sc_hd__decap_3
XFILLER_57_93 VGND VGND VPWR VPWR sky130_fd_sc_hd__decap_3
XFILLER_63_513 VGND VGND VPWR VPWR sky130_fd_sc_hd__decap_3
XFILLER_75_340 VGND VGND VPWR VPWR sky130_fd_sc_hd__decap_3
XFILLER_63_546 VGND VGND VPWR VPWR sky130_fd_sc_hd__decap_3
XFILLER_90_321 VGND VGND VPWR VPWR sky130_fd_sc_hd__decap_3
XFILLER_16_451 VGND VGND VPWR VPWR sky130_fd_sc_hd__decap_3
XFILLER_35_248 VGND VGND VPWR VPWR sky130_fd_sc_hd__decap_3
XFILLER_90_354 VGND VGND VPWR VPWR sky130_fd_sc_hd__decap_3
XFILLER_90_365 VGND VGND VPWR VPWR sky130_fd_sc_hd__decap_3
XTAP_TAPCELL_ROW_18_468 VGND VPWR sky130_fd_sc_hd__tapvpwrvgnd_1
XFILLER_50_229 VGND VGND VPWR VPWR sky130_fd_sc_hd__decap_3
XFILLER_73_81 VGND VGND VPWR VPWR sky130_fd_sc_hd__decap_3
XTAP_TAPCELL_ROW_46_799 VGND VPWR sky130_fd_sc_hd__tapvpwrvgnd_1
XFILLER_31_421 VGND VGND VPWR VPWR sky130_fd_sc_hd__decap_3
XFILLER_43_281 VGND VGND VPWR VPWR sky130_fd_sc_hd__decap_3
X_3890_ _6963_/Q _3890_/A2 _3890_/B1 _6945_/Q VGND VGND VPWR VPWR _3890_/X sky130_fd_sc_hd__a22o_2
XFILLER_31_454 VGND VGND VPWR VPWR sky130_fd_sc_hd__decap_3
XTAP_TAPCELL_ROW_100_1452 VGND VPWR sky130_fd_sc_hd__tapvpwrvgnd_1
XFILLER_78_3 VGND VGND VPWR VPWR sky130_fd_sc_hd__decap_3
XFILLER_8_672 VGND VGND VPWR VPWR sky130_fd_sc_hd__decap_3
XFILLER_7_160 VGND VGND VPWR VPWR sky130_fd_sc_hd__decap_3
XFILLER_7_193 VGND VGND VPWR VPWR sky130_fd_sc_hd__decap_3
X_7230_ _7401_/CLK _7230_/D _6510_/Y VGND VGND VPWR VPWR _7230_/Q sky130_fd_sc_hd__dfrtp_2
X_4442_ _4813_/A _4827_/A VGND VGND VPWR VPWR _4779_/A sky130_fd_sc_hd__or2_2
X_7161_ clkload6/A _7161_/D _6441_/Y VGND VGND VPWR VPWR _7161_/Q sky130_fd_sc_hd__dfrtp_2
X_4373_ _5018_/A _5018_/B VGND VGND VPWR VPWR _4373_/Y sky130_fd_sc_hd__nand2_2
XFILLER_98_421 VGND VGND VPWR VPWR sky130_fd_sc_hd__decap_3
X_7092_ clkload5/A _7092_/D _6372_/Y VGND VGND VPWR VPWR _7092_/Q sky130_fd_sc_hd__dfrtp_2
X_3324_ _3327_/A _4467_/A _4696_/B VGND VGND VPWR VPWR _3324_/X sky130_fd_sc_hd__or3_2
XFILLER_98_465 VGND VGND VPWR VPWR sky130_fd_sc_hd__decap_3
XFILLER_100_404 VGND VGND VPWR VPWR sky130_fd_sc_hd__decap_3
XFILLER_112_253 VGND VGND VPWR VPWR sky130_fd_sc_hd__decap_3
XFILLER_112_286 VGND VGND VPWR VPWR sky130_fd_sc_hd__decap_3
XFILLER_58_318 VGND VGND VPWR VPWR sky130_fd_sc_hd__decap_3
XFILLER_58_329 VGND VGND VPWR VPWR sky130_fd_sc_hd__decap_3
XFILLER_86_627 VGND VGND VPWR VPWR sky130_fd_sc_hd__decap_3
XTAP_TAPCELL_ROW_111_1581 VGND VPWR sky130_fd_sc_hd__tapvpwrvgnd_1
XFILLER_98_498 VGND VGND VPWR VPWR sky130_fd_sc_hd__decap_3
XFILLER_100_448 VGND VGND VPWR VPWR sky130_fd_sc_hd__fill_2
XFILLER_39_532 VGND VGND VPWR VPWR sky130_fd_sc_hd__decap_3
XFILLER_85_148 VGND VGND VPWR VPWR sky130_fd_sc_hd__decap_3
XFILLER_66_362 VGND VGND VPWR VPWR sky130_fd_sc_hd__fill_2
XTAP_TAPCELL_ROW_37_700 VGND VPWR sky130_fd_sc_hd__tapvpwrvgnd_1
XFILLER_26_215 VGND VGND VPWR VPWR sky130_fd_sc_hd__decap_3
XFILLER_81_332 VGND VGND VPWR VPWR sky130_fd_sc_hd__decap_3
XFILLER_53_18 VGND VGND VPWR VPWR sky130_fd_sc_hd__decap_3
XFILLER_81_343 VGND VGND VPWR VPWR sky130_fd_sc_hd__decap_3
X_6945_ _6978_/CLK _6945_/D VGND VGND VPWR VPWR _6945_/Q sky130_fd_sc_hd__dfxtp_2
XFILLER_22_410 VGND VGND VPWR VPWR sky130_fd_sc_hd__decap_3
XFILLER_41_218 VGND VGND VPWR VPWR sky130_fd_sc_hd__decap_3
XFILLER_41_229 VGND VGND VPWR VPWR sky130_fd_sc_hd__decap_3
XFILLER_81_376 VGND VGND VPWR VPWR sky130_fd_sc_hd__decap_3
XFILLER_22_421 VGND VGND VPWR VPWR sky130_fd_sc_hd__decap_3
XFILLER_34_292 VGND VGND VPWR VPWR sky130_fd_sc_hd__decap_3
X_6876_ _7390_/CLK _6876_/D VGND VGND VPWR VPWR _6876_/Q sky130_fd_sc_hd__dfxtp_2
XFILLER_5_119 VGND VGND VPWR VPWR sky130_fd_sc_hd__decap_3
X_4709_ _7002_/Q _7003_/Q _4826_/A VGND VGND VPWR VPWR _4801_/A sky130_fd_sc_hd__and3_2
XFILLER_108_548 VGND VGND VPWR VPWR sky130_fd_sc_hd__decap_3
XFILLER_116_592 VGND VGND VPWR VPWR sky130_fd_sc_hd__decap_3
XFILLER_78_26 VGND VGND VPWR VPWR sky130_fd_sc_hd__fill_2
XFILLER_78_37 VGND VGND VPWR VPWR sky130_fd_sc_hd__decap_3
XFILLER_89_432 VGND VGND VPWR VPWR sky130_fd_sc_hd__decap_3
X_7359_ _7359_/CLK _7359_/D _6639_/Y VGND VGND VPWR VPWR _7359_/Q sky130_fd_sc_hd__dfrtp_2
Xhold650 _6933_/Q VGND VGND VPWR VPWR _6933_/D sky130_fd_sc_hd__dlygate4sd3_1
Xhold661 _6803_/Q VGND VGND VPWR VPWR _6803_/D sky130_fd_sc_hd__dlygate4sd3_1
Xhold672 _6918_/Q VGND VGND VPWR VPWR _6918_/D sky130_fd_sc_hd__dlygate4sd3_1
XFILLER_103_220 VGND VGND VPWR VPWR sky130_fd_sc_hd__decap_3
XFILLER_103_231 VGND VGND VPWR VPWR sky130_fd_sc_hd__decap_3
Xhold683 _6948_/Q VGND VGND VPWR VPWR _6948_/D sky130_fd_sc_hd__dlygate4sd3_1
Xhold694 _6937_/Q VGND VGND VPWR VPWR _6937_/D sky130_fd_sc_hd__dlygate4sd3_1
XFILLER_49_318 VGND VGND VPWR VPWR sky130_fd_sc_hd__decap_3
XFILLER_89_476 VGND VGND VPWR VPWR sky130_fd_sc_hd__decap_3
XFILLER_57_340 VGND VGND VPWR VPWR sky130_fd_sc_hd__decap_3
XFILLER_85_671 VGND VGND VPWR VPWR sky130_fd_sc_hd__fill_1
XFILLER_91_107 VGND VGND VPWR VPWR sky130_fd_sc_hd__decap_3
XFILLER_92_619 VGND VGND VPWR VPWR sky130_fd_sc_hd__decap_3
XFILLER_94_47 VGND VGND VPWR VPWR sky130_fd_sc_hd__decap_3
XFILLER_27_41 VGND VGND VPWR VPWR sky130_fd_sc_hd__decap_3
XFILLER_27_63 VGND VGND VPWR VPWR sky130_fd_sc_hd__decap_3
XFILLER_45_524 VGND VGND VPWR VPWR sky130_fd_sc_hd__decap_3
XFILLER_57_373 VGND VGND VPWR VPWR sky130_fd_sc_hd__decap_3
XFILLER_72_321 VGND VGND VPWR VPWR sky130_fd_sc_hd__decap_3
XFILLER_85_682 VGND VGND VPWR VPWR sky130_fd_sc_hd__decap_3
XFILLER_17_248 VGND VGND VPWR VPWR sky130_fd_sc_hd__decap_3
XFILLER_72_365 VGND VGND VPWR VPWR sky130_fd_sc_hd__decap_3
XFILLER_13_410 VGND VGND VPWR VPWR sky130_fd_sc_hd__decap_3
XFILLER_32_207 VGND VGND VPWR VPWR sky130_fd_sc_hd__decap_3
XFILLER_72_398 VGND VGND VPWR VPWR sky130_fd_sc_hd__decap_3
XFILLER_25_281 VGND VGND VPWR VPWR sky130_fd_sc_hd__decap_3
XTAP_TAPCELL_ROW_43_769 VGND VPWR sky130_fd_sc_hd__tapvpwrvgnd_1
XTAP_TAPCELL_ROW_15_427 VGND VPWR sky130_fd_sc_hd__tapvpwrvgnd_1
XFILLER_40_262 VGND VGND VPWR VPWR sky130_fd_sc_hd__decap_3
XFILLER_13_498 VGND VGND VPWR VPWR sky130_fd_sc_hd__decap_3
XFILLER_64_9 VGND VGND VPWR VPWR sky130_fd_sc_hd__decap_3
XFILLER_114_507 VGND VGND VPWR VPWR sky130_fd_sc_hd__decap_3
XFILLER_4_141 VGND VGND VPWR VPWR sky130_fd_sc_hd__decap_3
XFILLER_5_642 VGND VGND VPWR VPWR sky130_fd_sc_hd__fill_2
XFILLER_4_152 VGND VGND VPWR VPWR sky130_fd_sc_hd__decap_3
XFILLER_4_185 VGND VGND VPWR VPWR sky130_fd_sc_hd__decap_3
XFILLER_4_23 VGND VGND VPWR VPWR sky130_fd_sc_hd__decap_3
XFILLER_4_45 VGND VGND VPWR VPWR sky130_fd_sc_hd__decap_3
XFILLER_68_638 VGND VGND VPWR VPWR sky130_fd_sc_hd__decap_3
XFILLER_95_402 VGND VGND VPWR VPWR sky130_fd_sc_hd__decap_3
XFILLER_95_435 VGND VGND VPWR VPWR sky130_fd_sc_hd__decap_3
XFILLER_67_159 VGND VGND VPWR VPWR sky130_fd_sc_hd__decap_3
XFILLER_95_479 VGND VGND VPWR VPWR sky130_fd_sc_hd__decap_3
XFILLER_48_373 VGND VGND VPWR VPWR sky130_fd_sc_hd__decap_3
XFILLER_75_181 VGND VGND VPWR VPWR sky130_fd_sc_hd__decap_3
XFILLER_82_118 VGND VGND VPWR VPWR sky130_fd_sc_hd__fill_1
XFILLER_63_332 VGND VGND VPWR VPWR sky130_fd_sc_hd__decap_3
XFILLER_63_343 VGND VGND VPWR VPWR sky130_fd_sc_hd__decap_3
Xplace321 _4418_/A2 VGND VGND VPWR VPWR _4422_/A2 sky130_fd_sc_hd__buf_2
Xplace310 _3548_/X VGND VGND VPWR VPWR _4948_/A sky130_fd_sc_hd__buf_2
XFILLER_51_516 VGND VGND VPWR VPWR sky130_fd_sc_hd__fill_2
XFILLER_63_376 VGND VGND VPWR VPWR sky130_fd_sc_hd__decap_3
XFILLER_91_685 VGND VGND VPWR VPWR sky130_fd_sc_hd__fill_1
Xplace354 _5136_/S VGND VGND VPWR VPWR _5132_/S sky130_fd_sc_hd__buf_2
Xplace343 _4606_/Y VGND VGND VPWR VPWR _5092_/C sky130_fd_sc_hd__buf_2
Xplace332 _4195_/A2 VGND VGND VPWR VPWR _4434_/B1 sky130_fd_sc_hd__buf_2
X_6730_ _6972_/CLK _6730_/D VGND VGND VPWR VPWR _6730_/Q sky130_fd_sc_hd__dfxtp_2
X_4991_ _5004_/A _5004_/B _4988_/A VGND VGND VPWR VPWR _4991_/Y sky130_fd_sc_hd__a21oi_2
XFILLER_16_292 VGND VGND VPWR VPWR sky130_fd_sc_hd__decap_3
XFILLER_90_184 VGND VGND VPWR VPWR sky130_fd_sc_hd__decap_3
Xplace387 _3334_/Y VGND VGND VPWR VPWR _3339_/C1 sky130_fd_sc_hd__buf_2
Xplace398 _5340_/S VGND VGND VPWR VPWR _5325_/S sky130_fd_sc_hd__buf_2
Xplace376 _3757_/S VGND VGND VPWR VPWR _3818_/A2 sky130_fd_sc_hd__buf_2
Xplace365 _4265_/B VGND VGND VPWR VPWR _4432_/A2 sky130_fd_sc_hd__buf_2
XFILLER_31_251 VGND VGND VPWR VPWR sky130_fd_sc_hd__decap_3
X_6661_ _6686_/A VGND VGND VPWR VPWR _6661_/Y sky130_fd_sc_hd__inv_2
X_3873_ _3733_/X _3870_/X _3872_/X _3682_/A VGND VGND VPWR VPWR _3874_/B sky130_fd_sc_hd__a22o_2
XFILLER_31_284 VGND VGND VPWR VPWR sky130_fd_sc_hd__decap_3
X_6592_ _6634_/A VGND VGND VPWR VPWR _6592_/Y sky130_fd_sc_hd__inv_2
XFILLER_8_480 VGND VGND VPWR VPWR sky130_fd_sc_hd__fill_2
XFILLER_105_529 VGND VGND VPWR VPWR sky130_fd_sc_hd__fill_1
X_7213_ _7403_/CLK _7213_/D _6493_/Y VGND VGND VPWR VPWR _7213_/Q sky130_fd_sc_hd__dfrtp_2
X_4425_ _4425_/A _4649_/B _4425_/C VGND VGND VPWR VPWR _4426_/B sky130_fd_sc_hd__and3_2
XTAP_TAPCELL_ROW_113_1610 VGND VPWR sky130_fd_sc_hd__tapvpwrvgnd_1
XFILLER_113_551 VGND VGND VPWR VPWR sky130_fd_sc_hd__decap_3
X_7144_ _7365_/CLK _7144_/D _6424_/Y VGND VGND VPWR VPWR _7144_/Q sky130_fd_sc_hd__dfrtp_2
X_4356_ _7012_/Q _4356_/A2 _4270_/B _7353_/Q _4355_/X VGND VGND VPWR VPWR _4356_/X
+ sky130_fd_sc_hd__a221o_2
XFILLER_48_29 VGND VGND VPWR VPWR sky130_fd_sc_hd__decap_3
XFILLER_86_413 VGND VGND VPWR VPWR sky130_fd_sc_hd__decap_3
XFILLER_86_424 VGND VGND VPWR VPWR sky130_fd_sc_hd__decap_3
XFILLER_100_234 VGND VGND VPWR VPWR sky130_fd_sc_hd__decap_3
X_7075_ _7330_/CLK _7075_/D _6355_/Y VGND VGND VPWR VPWR _7075_/Q sky130_fd_sc_hd__dfrtp_2
X_4287_ _7286_/Q _5159_/S _4334_/B1 _7158_/Q VGND VGND VPWR VPWR _4288_/D sky130_fd_sc_hd__a22o_2
XFILLER_100_256 VGND VGND VPWR VPWR sky130_fd_sc_hd__decap_3
XFILLER_104_24 VGND VGND VPWR VPWR sky130_fd_sc_hd__decap_3
XFILLER_104_35 VGND VGND VPWR VPWR sky130_fd_sc_hd__decap_3
XFILLER_39_340 VGND VGND VPWR VPWR sky130_fd_sc_hd__decap_3
XFILLER_58_159 VGND VGND VPWR VPWR sky130_fd_sc_hd__decap_3
XFILLER_100_289 VGND VGND VPWR VPWR sky130_fd_sc_hd__decap_3
XFILLER_104_68 VGND VGND VPWR VPWR sky130_fd_sc_hd__decap_3
XFILLER_39_384 VGND VGND VPWR VPWR sky130_fd_sc_hd__decap_3
XFILLER_27_557 VGND VGND VPWR VPWR sky130_fd_sc_hd__decap_3
XFILLER_54_332 VGND VGND VPWR VPWR sky130_fd_sc_hd__decap_3
XFILLER_64_39 VGND VGND VPWR VPWR sky130_fd_sc_hd__fill_2
XFILLER_82_652 VGND VGND VPWR VPWR sky130_fd_sc_hd__decap_3
XFILLER_42_505 VGND VGND VPWR VPWR sky130_fd_sc_hd__fill_2
XFILLER_54_365 VGND VGND VPWR VPWR sky130_fd_sc_hd__decap_3
XFILLER_54_376 VGND VGND VPWR VPWR sky130_fd_sc_hd__decap_3
XTAP_TAPCELL_ROW_64_1019 VGND VPWR sky130_fd_sc_hd__tapvpwrvgnd_1
XFILLER_81_184 VGND VGND VPWR VPWR sky130_fd_sc_hd__decap_3
Xfanout22 _6600_/A VGND VGND VPWR VPWR _6632_/A sky130_fd_sc_hd__clkdlybuf4s25_1
X_6928_ _7390_/CLK _6928_/D VGND VGND VPWR VPWR _6928_/Q sky130_fd_sc_hd__dfxtp_2
XFILLER_22_251 VGND VGND VPWR VPWR sky130_fd_sc_hd__fill_1
XFILLER_80_27 VGND VGND VPWR VPWR sky130_fd_sc_hd__fill_1
XFILLER_80_38 VGND VGND VPWR VPWR sky130_fd_sc_hd__decap_3
Xfanout33 fanout38/X VGND VGND VPWR VPWR _6473_/A sky130_fd_sc_hd__buf_1
Xfanout44 _6643_/A VGND VGND VPWR VPWR _6642_/A sky130_fd_sc_hd__buf_2
Xfanout55 _6684_/A VGND VGND VPWR VPWR _6674_/A sky130_fd_sc_hd__buf_2
X_6859_ _6972_/CLK _6859_/D VGND VGND VPWR VPWR _6859_/Q sky130_fd_sc_hd__dfxtp_2
XFILLER_10_424 VGND VGND VPWR VPWR sky130_fd_sc_hd__decap_3
XFILLER_10_435 VGND VGND VPWR VPWR sky130_fd_sc_hd__decap_3
XFILLER_13_32 VGND VGND VPWR VPWR sky130_fd_sc_hd__decap_3
XFILLER_22_262 VGND VGND VPWR VPWR sky130_fd_sc_hd__decap_3
XFILLER_22_284 VGND VGND VPWR VPWR sky130_fd_sc_hd__decap_3
XFILLER_50_571 VGND VGND VPWR VPWR sky130_fd_sc_hd__fill_2
XFILLER_50_582 VGND VGND VPWR VPWR sky130_fd_sc_hd__decap_3
Xfanout66 _6619_/A VGND VGND VPWR VPWR _6651_/A sky130_fd_sc_hd__buf_2
XTAP_TAPCELL_ROW_40_728 VGND VPWR sky130_fd_sc_hd__tapvpwrvgnd_1
XFILLER_108_312 VGND VGND VPWR VPWR sky130_fd_sc_hd__decap_3
XFILLER_108_345 VGND VGND VPWR VPWR sky130_fd_sc_hd__decap_3
XTAP_TAPCELL_ROW_20_496 VGND VPWR sky130_fd_sc_hd__tapvpwrvgnd_1
XFILLER_108_389 VGND VGND VPWR VPWR sky130_fd_sc_hd__decap_3
XFILLER_89_69 VGND VGND VPWR VPWR sky130_fd_sc_hd__decap_3
XTAP_TAPCELL_ROW_75_1148 VGND VPWR sky130_fd_sc_hd__tapvpwrvgnd_1
XFILLER_2_645 VGND VGND VPWR VPWR sky130_fd_sc_hd__fill_1
XFILLER_89_240 VGND VGND VPWR VPWR sky130_fd_sc_hd__decap_3
XFILLER_77_402 VGND VGND VPWR VPWR sky130_fd_sc_hd__decap_3
XFILLER_89_262 VGND VGND VPWR VPWR sky130_fd_sc_hd__fill_1
XFILLER_1_177 VGND VGND VPWR VPWR sky130_fd_sc_hd__fill_1
XFILLER_1_199 VGND VGND VPWR VPWR sky130_fd_sc_hd__decap_3
XFILLER_49_137 VGND VGND VPWR VPWR sky130_fd_sc_hd__decap_3
XFILLER_77_435 VGND VGND VPWR VPWR sky130_fd_sc_hd__decap_3
XFILLER_77_457 VGND VGND VPWR VPWR sky130_fd_sc_hd__decap_3
XFILLER_38_51 VGND VGND VPWR VPWR sky130_fd_sc_hd__decap_3
XFILLER_92_416 VGND VGND VPWR VPWR sky130_fd_sc_hd__decap_3
XFILLER_45_310 VGND VGND VPWR VPWR sky130_fd_sc_hd__decap_3
XFILLER_64_129 VGND VGND VPWR VPWR sky130_fd_sc_hd__decap_3
XTAP_TAPCELL_ROW_48_828 VGND VPWR sky130_fd_sc_hd__tapvpwrvgnd_1
XFILLER_45_343 VGND VGND VPWR VPWR sky130_fd_sc_hd__decap_3
XFILLER_57_192 VGND VGND VPWR VPWR sky130_fd_sc_hd__decap_3
Xhold1180 _7139_/Q VGND VGND VPWR VPWR _5388_/A0 sky130_fd_sc_hd__dlygate4sd3_1
Xhold1191 _7163_/Q VGND VGND VPWR VPWR _5336_/A0 sky130_fd_sc_hd__dlygate4sd3_1
XFILLER_54_50 VGND VGND VPWR VPWR sky130_fd_sc_hd__decap_3
XTAP_TAPCELL_ROW_86_1288 VGND VPWR sky130_fd_sc_hd__tapvpwrvgnd_1
XFILLER_60_346 VGND VGND VPWR VPWR sky130_fd_sc_hd__decap_3
XTAP_TAPCELL_ROW_28_585 VGND VPWR sky130_fd_sc_hd__tapvpwrvgnd_1
XFILLER_13_240 VGND VGND VPWR VPWR sky130_fd_sc_hd__decap_3
XFILLER_60_379 VGND VGND VPWR VPWR sky130_fd_sc_hd__decap_3
XFILLER_13_262 VGND VGND VPWR VPWR sky130_fd_sc_hd__decap_3
XFILLER_13_284 VGND VGND VPWR VPWR sky130_fd_sc_hd__decap_3
XFILLER_9_211 VGND VGND VPWR VPWR sky130_fd_sc_hd__decap_3
XFILLER_70_60 VGND VGND VPWR VPWR sky130_fd_sc_hd__decap_3
XFILLER_9_255 VGND VGND VPWR VPWR sky130_fd_sc_hd__decap_3
Xclkload14 _7351_/CLK VGND VGND VPWR VPWR clkload14/X sky130_fd_sc_hd__clkbuf_8
Xclkload25 _7330_/CLK VGND VGND VPWR VPWR clkload25/X sky130_fd_sc_hd__clkbuf_1
Xclkload36 _7338_/CLK VGND VGND VPWR VPWR clkload36/Y sky130_fd_sc_hd__clkinv_2
XFILLER_114_315 VGND VGND VPWR VPWR sky130_fd_sc_hd__decap_3
X_4210_ _4095_/A _4210_/B VGND VGND VPWR VPWR _4210_/X sky130_fd_sc_hd__and2b_2
XPHY_EDGE_ROW_10_Left_127 VGND VGND VPWR VPWR sky130_fd_sc_hd__decap_3
XFILLER_68_413 VGND VGND VPWR VPWR sky130_fd_sc_hd__decap_3
X_5190_ _7233_/Q _5190_/B VGND VGND VPWR VPWR _7233_/D sky130_fd_sc_hd__and2_2
XFILLER_110_521 VGND VGND VPWR VPWR sky130_fd_sc_hd__fill_2
XFILLER_68_424 VGND VGND VPWR VPWR sky130_fd_sc_hd__decap_3
X_4141_ _4141_/A _4141_/B VGND VGND VPWR VPWR _4142_/B sky130_fd_sc_hd__nor2_2
XFILLER_95_243 VGND VGND VPWR VPWR sky130_fd_sc_hd__decap_3
X_4072_ _7243_/Q _4430_/A2 _4430_/B1 _7179_/Q _4071_/X VGND VGND VPWR VPWR _4072_/X
+ sky130_fd_sc_hd__a221o_2
XFILLER_110_598 VGND VGND VPWR VPWR sky130_fd_sc_hd__fill_1
XFILLER_49_671 VGND VGND VPWR VPWR sky130_fd_sc_hd__fill_1
XFILLER_55_129 VGND VGND VPWR VPWR sky130_fd_sc_hd__decap_3
XFILLER_83_449 VGND VGND VPWR VPWR sky130_fd_sc_hd__fill_2
XFILLER_95_276 VGND VGND VPWR VPWR sky130_fd_sc_hd__decap_3
XFILLER_95_298 VGND VGND VPWR VPWR sky130_fd_sc_hd__decap_3
XFILLER_36_321 VGND VGND VPWR VPWR sky130_fd_sc_hd__decap_3
XFILLER_48_192 VGND VGND VPWR VPWR sky130_fd_sc_hd__decap_3
XFILLER_51_302 VGND VGND VPWR VPWR sky130_fd_sc_hd__decap_3
XFILLER_36_398 VGND VGND VPWR VPWR sky130_fd_sc_hd__decap_3
XFILLER_51_335 VGND VGND VPWR VPWR sky130_fd_sc_hd__fill_1
XFILLER_51_346 VGND VGND VPWR VPWR sky130_fd_sc_hd__decap_3
X_4974_ _6993_/Q _4983_/B VGND VGND VPWR VPWR _4975_/B sky130_fd_sc_hd__xor2_2
X_6713_ _7404_/CLK _6713_/D VGND VGND VPWR VPWR _6713_/Q sky130_fd_sc_hd__dfxtp_2
X_3925_ _6687_/Q _3925_/A2 _3925_/B1 _6865_/Q VGND VGND VPWR VPWR _3925_/X sky130_fd_sc_hd__a22o_2
X_6644_ _6644_/A VGND VGND VPWR VPWR _6644_/Y sky130_fd_sc_hd__inv_2
XFILLER_50_19 VGND VGND VPWR VPWR sky130_fd_sc_hd__decap_3
Xclkload8 clkload8/A VGND VGND VPWR VPWR clkload8/X sky130_fd_sc_hd__clkbuf_16
X_3856_ _3845_/X _3855_/X _5138_/S VGND VGND VPWR VPWR _3856_/X sky130_fd_sc_hd__o21a_2
X_6575_ _6608_/A VGND VGND VPWR VPWR _6575_/Y sky130_fd_sc_hd__inv_2
X_3787_ _6739_/Q _3651_/Y _3852_/B1 _6745_/Q _3786_/X VGND VGND VPWR VPWR _3787_/X
+ sky130_fd_sc_hd__a221o_2
XFILLER_105_315 VGND VGND VPWR VPWR sky130_fd_sc_hd__decap_3
XFILLER_105_337 VGND VGND VPWR VPWR sky130_fd_sc_hd__decap_3
XFILLER_59_39 VGND VGND VPWR VPWR sky130_fd_sc_hd__decap_3
Xoutput552 _4697_/A VGND VGND VPWR VPWR pc_out[6] sky130_fd_sc_hd__clkdlybuf4s25_1
Xoutput541 _7002_/Q VGND VGND VPWR VPWR pc_out[25] sky130_fd_sc_hd__clkdlybuf4s25_1
Xoutput530 _6992_/Q VGND VGND VPWR VPWR pc_out[15] sky130_fd_sc_hd__clkdlybuf4s25_1
X_4408_ _7024_/Q _4422_/A2 _4404_/X _4407_/X VGND VGND VPWR VPWR _4409_/B sky130_fd_sc_hd__a211o_2
XFILLER_59_402 VGND VGND VPWR VPWR sky130_fd_sc_hd__decap_3
X_5388_ _5388_/A0 _4913_/X _5398_/S VGND VGND VPWR VPWR _7139_/D sky130_fd_sc_hd__mux2_2
XFILLER_113_370 VGND VGND VPWR VPWR sky130_fd_sc_hd__decap_3
XFILLER_59_435 VGND VGND VPWR VPWR sky130_fd_sc_hd__decap_3
XFILLER_86_221 VGND VGND VPWR VPWR sky130_fd_sc_hd__decap_3
X_7127_ clkload5/A _7127_/D _6407_/Y VGND VGND VPWR VPWR _7127_/Q sky130_fd_sc_hd__dfrtp_2
X_4339_ _7287_/Q _4522_/S _4339_/B1 _7159_/Q VGND VGND VPWR VPWR _4339_/X sky130_fd_sc_hd__a22o_2
X_7058_ clkload4/A _7058_/D _6338_/Y VGND VGND VPWR VPWR _7058_/Q sky130_fd_sc_hd__dfstp_2
XTAP_TAPCELL_ROW_70_1089 VGND VPWR sky130_fd_sc_hd__tapvpwrvgnd_1
XFILLER_101_587 VGND VGND VPWR VPWR sky130_fd_sc_hd__decap_3
XFILLER_46_118 VGND VGND VPWR VPWR sky130_fd_sc_hd__decap_3
XFILLER_74_449 VGND VGND VPWR VPWR sky130_fd_sc_hd__decap_3
XFILLER_86_276 VGND VGND VPWR VPWR sky130_fd_sc_hd__decap_3
XFILLER_27_343 VGND VGND VPWR VPWR sky130_fd_sc_hd__decap_3
XFILLER_67_490 VGND VGND VPWR VPWR sky130_fd_sc_hd__decap_3
XFILLER_27_376 VGND VGND VPWR VPWR sky130_fd_sc_hd__decap_3
XFILLER_42_302 VGND VGND VPWR VPWR sky130_fd_sc_hd__decap_3
XFILLER_82_460 VGND VGND VPWR VPWR sky130_fd_sc_hd__decap_3
XFILLER_70_622 VGND VGND VPWR VPWR sky130_fd_sc_hd__fill_1
XFILLER_91_37 VGND VGND VPWR VPWR sky130_fd_sc_hd__decap_3
XFILLER_24_20 VGND VGND VPWR VPWR sky130_fd_sc_hd__decap_3
XFILLER_42_357 VGND VGND VPWR VPWR sky130_fd_sc_hd__decap_3
XFILLER_42_368 VGND VGND VPWR VPWR sky130_fd_sc_hd__fill_1
XFILLER_42_379 VGND VGND VPWR VPWR sky130_fd_sc_hd__decap_3
XFILLER_70_666 VGND VGND VPWR VPWR sky130_fd_sc_hd__decap_3
XTAP_TAPCELL_ROW_25_555 VGND VPWR sky130_fd_sc_hd__tapvpwrvgnd_1
XFILLER_24_53 VGND VGND VPWR VPWR sky130_fd_sc_hd__decap_3
XFILLER_24_75 VGND VGND VPWR VPWR sky130_fd_sc_hd__decap_3
XTAP_TAPCELL_ROW_53_886 VGND VPWR sky130_fd_sc_hd__tapvpwrvgnd_1
XFILLER_50_390 VGND VGND VPWR VPWR sky130_fd_sc_hd__decap_3
XFILLER_109_643 VGND VGND VPWR VPWR sky130_fd_sc_hd__decap_3
XFILLER_109_676 VGND VGND VPWR VPWR sky130_fd_sc_hd__decap_3
XFILLER_40_41 VGND VGND VPWR VPWR sky130_fd_sc_hd__decap_3
XFILLER_6_269 VGND VGND VPWR VPWR sky130_fd_sc_hd__decap_3
XFILLER_108_164 VGND VGND VPWR VPWR sky130_fd_sc_hd__decap_3
XFILLER_49_72 VGND VGND VPWR VPWR sky130_fd_sc_hd__decap_3
XFILLER_27_9 VGND VGND VPWR VPWR sky130_fd_sc_hd__decap_3
XFILLER_65_405 VGND VGND VPWR VPWR sky130_fd_sc_hd__decap_3
XFILLER_77_243 VGND VGND VPWR VPWR sky130_fd_sc_hd__decap_3
XFILLER_77_265 VGND VGND VPWR VPWR sky130_fd_sc_hd__fill_2
XTAP_TAPCELL_ROW_88_1306 VGND VPWR sky130_fd_sc_hd__tapvpwrvgnd_1
XFILLER_65_438 VGND VGND VPWR VPWR sky130_fd_sc_hd__decap_3
XFILLER_77_298 VGND VGND VPWR VPWR sky130_fd_sc_hd__fill_1
XFILLER_18_321 VGND VGND VPWR VPWR sky130_fd_sc_hd__decap_3
XFILLER_1_57 VGND VGND VPWR VPWR sky130_fd_sc_hd__decap_3
XFILLER_65_449 VGND VGND VPWR VPWR sky130_fd_sc_hd__decap_3
XFILLER_92_235 VGND VGND VPWR VPWR sky130_fd_sc_hd__decap_3
XFILLER_45_140 VGND VGND VPWR VPWR sky130_fd_sc_hd__decap_3
XFILLER_73_460 VGND VGND VPWR VPWR sky130_fd_sc_hd__decap_3
XFILLER_18_387 VGND VGND VPWR VPWR sky130_fd_sc_hd__decap_3
XFILLER_33_324 VGND VGND VPWR VPWR sky130_fd_sc_hd__decap_3
XFILLER_33_346 VGND VGND VPWR VPWR sky130_fd_sc_hd__decap_3
XFILLER_73_493 VGND VGND VPWR VPWR sky130_fd_sc_hd__decap_3
XFILLER_14_560 VGND VGND VPWR VPWR sky130_fd_sc_hd__fill_2
XFILLER_14_571 VGND VGND VPWR VPWR sky130_fd_sc_hd__decap_3
XFILLER_60_176 VGND VGND VPWR VPWR sky130_fd_sc_hd__decap_3
XFILLER_81_81 VGND VGND VPWR VPWR sky130_fd_sc_hd__decap_3
X_3710_ _3710_/A1 _4832_/A _3709_/X VGND VGND VPWR VPWR _7399_/D sky130_fd_sc_hd__o21a_2
XFILLER_41_390 VGND VGND VPWR VPWR sky130_fd_sc_hd__fill_2
X_4690_ _7005_/Q _5605_/B VGND VGND VPWR VPWR _4757_/A sky130_fd_sc_hd__and2_2
XTAP_TAPCELL_ROW_99_1435 VGND VPWR sky130_fd_sc_hd__tapvpwrvgnd_1
XFILLER_60_3 VGND VGND VPWR VPWR sky130_fd_sc_hd__decap_3
X_6360_ _6388_/A VGND VGND VPWR VPWR _6360_/Y sky130_fd_sc_hd__inv_2
X_3572_ _4295_/B _3607_/B VGND VGND VPWR VPWR _4292_/A sky130_fd_sc_hd__xnor2_2
X_6291_ _6535_/A VGND VGND VPWR VPWR _6291_/Y sky130_fd_sc_hd__inv_2
XFILLER_102_318 VGND VGND VPWR VPWR sky130_fd_sc_hd__decap_3
XFILLER_88_519 VGND VGND VPWR VPWR sky130_fd_sc_hd__decap_3
XFILLER_68_221 VGND VGND VPWR VPWR sky130_fd_sc_hd__decap_3
X_5173_ _5173_/A _5190_/B VGND VGND VPWR VPWR _7241_/D sky130_fd_sc_hd__and2_2
XFILLER_110_340 VGND VGND VPWR VPWR sky130_fd_sc_hd__decap_3
XFILLER_68_243 VGND VGND VPWR VPWR sky130_fd_sc_hd__decap_3
XFILLER_96_563 VGND VGND VPWR VPWR sky130_fd_sc_hd__decap_3
X_4124_ _4117_/Y _4124_/B VGND VGND VPWR VPWR _4126_/A sky130_fd_sc_hd__and2b_2
XFILLER_56_427 VGND VGND VPWR VPWR sky130_fd_sc_hd__decap_3
XFILLER_68_276 VGND VGND VPWR VPWR sky130_fd_sc_hd__decap_3
XFILLER_110_395 VGND VGND VPWR VPWR sky130_fd_sc_hd__decap_3
XFILLER_37_652 VGND VGND VPWR VPWR sky130_fd_sc_hd__decap_3
XFILLER_83_246 VGND VGND VPWR VPWR sky130_fd_sc_hd__decap_3
X_4055_ _4055_/A _4658_/A VGND VGND VPWR VPWR _4720_/A sky130_fd_sc_hd__nor2b_2
XFILLER_64_471 VGND VGND VPWR VPWR sky130_fd_sc_hd__decap_3
XFILLER_71_408 VGND VGND VPWR VPWR sky130_fd_sc_hd__decap_3
XTAP_TAPCELL_ROW_108_1553 VGND VPWR sky130_fd_sc_hd__tapvpwrvgnd_1
XTAP_TAPCELL_ROW_108_1542 VGND VPWR sky130_fd_sc_hd__tapvpwrvgnd_1
XFILLER_101_14 VGND VGND VPWR VPWR sky130_fd_sc_hd__decap_3
XFILLER_36_173 VGND VGND VPWR VPWR sky130_fd_sc_hd__decap_3
XFILLER_24_368 VGND VGND VPWR VPWR sky130_fd_sc_hd__decap_3
XFILLER_51_154 VGND VGND VPWR VPWR sky130_fd_sc_hd__decap_3
XFILLER_101_69 VGND VGND VPWR VPWR sky130_fd_sc_hd__decap_3
XFILLER_61_18 VGND VGND VPWR VPWR sky130_fd_sc_hd__decap_3
X_4957_ _4982_/B _5009_/A _6992_/Q VGND VGND VPWR VPWR _4983_/B sky130_fd_sc_hd__o21ai_2
XTAP_TAPCELL_ROW_22_514 VGND VPWR sky130_fd_sc_hd__tapvpwrvgnd_1
X_4888_ _4888_/A _4888_/B VGND VGND VPWR VPWR _4889_/B sky130_fd_sc_hd__or2_2
X_3908_ _3728_/B _3907_/X _5138_/S VGND VGND VPWR VPWR _3908_/X sky130_fd_sc_hd__o21a_2
XTAP_TAPCELL_ROW_50_856 VGND VPWR sky130_fd_sc_hd__tapvpwrvgnd_1
X_6627_ _6664_/A VGND VGND VPWR VPWR _6627_/Y sky130_fd_sc_hd__inv_2
X_3839_ _3746_/X _3836_/X _3838_/X _3733_/X VGND VGND VPWR VPWR _3845_/A sky130_fd_sc_hd__a22o_2
X_6558_ _6558_/A VGND VGND VPWR VPWR _6558_/Y sky130_fd_sc_hd__inv_2
XFILLER_106_657 VGND VGND VPWR VPWR sky130_fd_sc_hd__decap_3
XFILLER_10_22 VGND VGND VPWR VPWR sky130_fd_sc_hd__decap_3
X_6489_ _6584_/A VGND VGND VPWR VPWR _6489_/Y sky130_fd_sc_hd__inv_2
XFILLER_105_178 VGND VGND VPWR VPWR sky130_fd_sc_hd__decap_3
XFILLER_79_519 VGND VGND VPWR VPWR sky130_fd_sc_hd__decap_3
XTAP_TAPCELL_ROW_72_1118 VGND VPWR sky130_fd_sc_hd__tapvpwrvgnd_1
XFILLER_59_221 VGND VGND VPWR VPWR sky130_fd_sc_hd__decap_3
XFILLER_86_26 VGND VGND VPWR VPWR sky130_fd_sc_hd__fill_2
XFILLER_101_340 VGND VGND VPWR VPWR sky130_fd_sc_hd__fill_2
XFILLER_19_20 VGND VGND VPWR VPWR sky130_fd_sc_hd__decap_3
XFILLER_59_243 VGND VGND VPWR VPWR sky130_fd_sc_hd__decap_3
XFILLER_86_59 VGND VGND VPWR VPWR sky130_fd_sc_hd__decap_3
XFILLER_101_351 VGND VGND VPWR VPWR sky130_fd_sc_hd__decap_3
XFILLER_101_384 VGND VGND VPWR VPWR sky130_fd_sc_hd__decap_3
XFILLER_47_405 VGND VGND VPWR VPWR sky130_fd_sc_hd__decap_3
XFILLER_59_287 VGND VGND VPWR VPWR sky130_fd_sc_hd__decap_3
XFILLER_87_585 VGND VGND VPWR VPWR sky130_fd_sc_hd__decap_3
XFILLER_47_449 VGND VGND VPWR VPWR sky130_fd_sc_hd__decap_3
XFILLER_74_224 VGND VGND VPWR VPWR sky130_fd_sc_hd__decap_3
Xclkbuf_leaf_39_clk clkbuf_3_0__f_clk/X VGND VGND VPWR VPWR clkload3/A sky130_fd_sc_hd__clkbuf_16
XTAP_TAPCELL_ROW_58_945 VGND VPWR sky130_fd_sc_hd__tapvpwrvgnd_1
XFILLER_27_140 VGND VGND VPWR VPWR sky130_fd_sc_hd__decap_3
XTAP_TAPCELL_ROW_2_272 VGND VPWR sky130_fd_sc_hd__tapvpwrvgnd_1
XFILLER_15_313 VGND VGND VPWR VPWR sky130_fd_sc_hd__decap_3
XFILLER_27_184 VGND VGND VPWR VPWR sky130_fd_sc_hd__decap_3
XFILLER_35_30 VGND VGND VPWR VPWR sky130_fd_sc_hd__decap_3
XFILLER_42_121 VGND VGND VPWR VPWR sky130_fd_sc_hd__decap_3
XFILLER_15_346 VGND VGND VPWR VPWR sky130_fd_sc_hd__decap_3
XFILLER_35_63 VGND VGND VPWR VPWR sky130_fd_sc_hd__fill_2
XFILLER_70_441 VGND VGND VPWR VPWR sky130_fd_sc_hd__decap_3
XTAP_TAPCELL_ROW_83_1247 VGND VPWR sky130_fd_sc_hd__tapvpwrvgnd_1
XFILLER_35_96 VGND VGND VPWR VPWR sky130_fd_sc_hd__decap_3
XFILLER_70_474 VGND VGND VPWR VPWR sky130_fd_sc_hd__fill_2
XFILLER_11_530 VGND VGND VPWR VPWR sky130_fd_sc_hd__decap_3
XFILLER_30_338 VGND VGND VPWR VPWR sky130_fd_sc_hd__decap_3
XFILLER_51_40 VGND VGND VPWR VPWR sky130_fd_sc_hd__decap_3
XFILLER_7_501 VGND VGND VPWR VPWR sky130_fd_sc_hd__decap_3
XFILLER_109_440 VGND VGND VPWR VPWR sky130_fd_sc_hd__decap_3
XFILLER_51_84 VGND VGND VPWR VPWR sky130_fd_sc_hd__decap_3
XFILLER_51_95 VGND VGND VPWR VPWR sky130_fd_sc_hd__decap_3
XFILLER_97_305 VGND VGND VPWR VPWR sky130_fd_sc_hd__decap_3
XTAP_TAPCELL_ROW_94_1376 VGND VPWR sky130_fd_sc_hd__tapvpwrvgnd_1
XFILLER_105_690 VGND VGND VPWR VPWR sky130_fd_sc_hd__fill_2
XFILLER_111_104 VGND VGND VPWR VPWR sky130_fd_sc_hd__fill_1
XFILLER_97_327 VGND VGND VPWR VPWR sky130_fd_sc_hd__decap_3
XFILLER_25_6 VGND VGND VPWR VPWR sky130_fd_sc_hd__decap_3
XFILLER_65_202 VGND VGND VPWR VPWR sky130_fd_sc_hd__decap_3
XFILLER_93_511 VGND VGND VPWR VPWR sky130_fd_sc_hd__fill_1
XFILLER_38_449 VGND VGND VPWR VPWR sky130_fd_sc_hd__decap_3
XFILLER_65_257 VGND VGND VPWR VPWR sky130_fd_sc_hd__decap_3
XFILLER_93_533 VGND VGND VPWR VPWR sky130_fd_sc_hd__decap_3
XFILLER_80_216 VGND VGND VPWR VPWR sky130_fd_sc_hd__decap_3
XFILLER_93_588 VGND VGND VPWR VPWR sky130_fd_sc_hd__decap_3
XFILLER_18_184 VGND VGND VPWR VPWR sky130_fd_sc_hd__decap_3
XFILLER_80_249 VGND VGND VPWR VPWR sky130_fd_sc_hd__decap_3
XFILLER_33_132 VGND VGND VPWR VPWR sky130_fd_sc_hd__decap_3
XFILLER_61_452 VGND VGND VPWR VPWR sky130_fd_sc_hd__decap_3
X_4811_ _4652_/B _4811_/B _4811_/C VGND VGND VPWR VPWR _4811_/X sky130_fd_sc_hd__and3b_2
XFILLER_21_316 VGND VGND VPWR VPWR sky130_fd_sc_hd__decap_3
XFILLER_33_187 VGND VGND VPWR VPWR sky130_fd_sc_hd__decap_3
XFILLER_92_91 VGND VGND VPWR VPWR sky130_fd_sc_hd__decap_3
XFILLER_21_349 VGND VGND VPWR VPWR sky130_fd_sc_hd__decap_3
X_4742_ _4745_/A _4081_/X _4454_/X _4969_/B VGND VGND VPWR VPWR _4742_/Y sky130_fd_sc_hd__o211ai_2
XTAP_TAPCELL_ROW_103_1483 VGND VPWR sky130_fd_sc_hd__tapvpwrvgnd_1
X_4673_ _4982_/B _4673_/B VGND VGND VPWR VPWR _4680_/A sky130_fd_sc_hd__or2_2
X_6412_ _6604_/A VGND VGND VPWR VPWR _6412_/Y sky130_fd_sc_hd__inv_2
X_3624_ _5114_/A _3600_/A _4614_/C _3635_/B VGND VGND VPWR VPWR _3624_/X sky130_fd_sc_hd__a22o_2
X_7392_ _7394_/CLK _7392_/D _6672_/Y VGND VGND VPWR VPWR _7392_/Q sky130_fd_sc_hd__dfrtp_2
X_6343_ _6347_/A VGND VGND VPWR VPWR _6343_/Y sky130_fd_sc_hd__inv_2
X_3555_ _7285_/Q _3562_/A _3366_/X _7157_/Q VGND VGND VPWR VPWR _3556_/C sky130_fd_sc_hd__a22o_2
XFILLER_0_209 VGND VGND VPWR VPWR sky130_fd_sc_hd__decap_3
X_6274_ _6275_/A VGND VGND VPWR VPWR _6274_/Y sky130_fd_sc_hd__inv_2
X_3486_ _3502_/A _3502_/B _3485_/C VGND VGND VPWR VPWR _5144_/B sky130_fd_sc_hd__o21ai_2
XFILLER_102_115 VGND VGND VPWR VPWR sky130_fd_sc_hd__decap_3
XFILLER_103_649 VGND VGND VPWR VPWR sky130_fd_sc_hd__decap_3
XFILLER_88_327 VGND VGND VPWR VPWR sky130_fd_sc_hd__decap_3
X_5225_ _5225_/A _5225_/B VGND VGND VPWR VPWR _7216_/D sky130_fd_sc_hd__and2_2
XFILLER_102_137 VGND VGND VPWR VPWR sky130_fd_sc_hd__decap_3
XFILLER_69_541 VGND VGND VPWR VPWR sky130_fd_sc_hd__fill_2
XFILLER_111_671 VGND VGND VPWR VPWR sky130_fd_sc_hd__fill_1
XFILLER_56_29 VGND VGND VPWR VPWR sky130_fd_sc_hd__decap_3
XFILLER_69_574 VGND VGND VPWR VPWR sky130_fd_sc_hd__decap_3
XFILLER_69_596 VGND VGND VPWR VPWR sky130_fd_sc_hd__decap_3
XFILLER_84_522 VGND VGND VPWR VPWR sky130_fd_sc_hd__decap_3
XFILLER_96_360 VGND VGND VPWR VPWR sky130_fd_sc_hd__decap_3
XFILLER_96_371 VGND VGND VPWR VPWR sky130_fd_sc_hd__decap_3
X_5156_ _7010_/D _5155_/X _5156_/S VGND VGND VPWR VPWR _5156_/X sky130_fd_sc_hd__mux2_2
XFILLER_56_224 VGND VGND VPWR VPWR sky130_fd_sc_hd__decap_3
XFILLER_84_533 VGND VGND VPWR VPWR sky130_fd_sc_hd__decap_3
X_5087_ _5101_/B _5100_/B _5086_/A _4365_/X VGND VGND VPWR VPWR _5087_/Y sky130_fd_sc_hd__a211oi_2
X_4107_ _7301_/Q _4417_/A2 _4218_/A2 _7109_/Q _4106_/X VGND VGND VPWR VPWR _4107_/X
+ sky130_fd_sc_hd__a221o_2
XFILLER_112_24 VGND VGND VPWR VPWR sky130_fd_sc_hd__decap_3
XFILLER_56_268 VGND VGND VPWR VPWR sky130_fd_sc_hd__decap_3
XFILLER_71_205 VGND VGND VPWR VPWR sky130_fd_sc_hd__decap_3
X_4038_ _4039_/A _4458_/A VGND VGND VPWR VPWR _4608_/B sky130_fd_sc_hd__nor2_2
XTAP_TAPCELL_ROW_55_915 VGND VPWR sky130_fd_sc_hd__tapvpwrvgnd_1
XFILLER_112_46 VGND VGND VPWR VPWR sky130_fd_sc_hd__decap_3
XFILLER_112_68 VGND VGND VPWR VPWR sky130_fd_sc_hd__decap_3
XFILLER_24_110 VGND VGND VPWR VPWR sky130_fd_sc_hd__decap_3
XFILLER_71_249 VGND VGND VPWR VPWR sky130_fd_sc_hd__decap_3
XTAP_TAPCELL_ROW_69_1080 VGND VPWR sky130_fd_sc_hd__tapvpwrvgnd_1
XFILLER_52_430 VGND VGND VPWR VPWR sky130_fd_sc_hd__decap_3
XFILLER_64_290 VGND VGND VPWR VPWR sky130_fd_sc_hd__decap_3
XFILLER_12_327 VGND VGND VPWR VPWR sky130_fd_sc_hd__decap_3
XFILLER_24_165 VGND VGND VPWR VPWR sky130_fd_sc_hd__decap_3
XFILLER_40_614 VGND VGND VPWR VPWR sky130_fd_sc_hd__decap_3
XFILLER_52_474 VGND VGND VPWR VPWR sky130_fd_sc_hd__fill_2
XTAP_TAPCELL_ROW_35_672 VGND VPWR sky130_fd_sc_hd__tapvpwrvgnd_1
XFILLER_8_309 VGND VGND VPWR VPWR sky130_fd_sc_hd__fill_1
XFILLER_20_360 VGND VGND VPWR VPWR sky130_fd_sc_hd__decap_3
XFILLER_20_371 VGND VGND VPWR VPWR sky130_fd_sc_hd__decap_3
XFILLER_20_393 VGND VGND VPWR VPWR sky130_fd_sc_hd__decap_3
XFILLER_21_21 VGND VGND VPWR VPWR sky130_fd_sc_hd__decap_3
XFILLER_21_43 VGND VGND VPWR VPWR sky130_fd_sc_hd__fill_1
XFILLER_21_54 VGND VGND VPWR VPWR sky130_fd_sc_hd__fill_2
XFILLER_108_3 VGND VGND VPWR VPWR sky130_fd_sc_hd__decap_3
XFILLER_21_98 VGND VGND VPWR VPWR sky130_fd_sc_hd__decap_3
XFILLER_106_454 VGND VGND VPWR VPWR sky130_fd_sc_hd__decap_3
XFILLER_97_36 VGND VGND VPWR VPWR sky130_fd_sc_hd__decap_3
XTAP_TAPCELL_ROW_7_331 VGND VPWR sky130_fd_sc_hd__tapvpwrvgnd_1
XFILLER_47_202 VGND VGND VPWR VPWR sky130_fd_sc_hd__decap_3
XFILLER_75_500 VGND VGND VPWR VPWR sky130_fd_sc_hd__decap_3
XFILLER_75_522 VGND VGND VPWR VPWR sky130_fd_sc_hd__decap_3
XFILLER_87_382 VGND VGND VPWR VPWR sky130_fd_sc_hd__decap_3
XFILLER_101_192 VGND VGND VPWR VPWR sky130_fd_sc_hd__decap_3
XFILLER_47_246 VGND VGND VPWR VPWR sky130_fd_sc_hd__decap_3
XFILLER_75_555 VGND VGND VPWR VPWR sky130_fd_sc_hd__decap_3
XFILLER_87_393 VGND VGND VPWR VPWR sky130_fd_sc_hd__decap_3
XFILLER_35_419 VGND VGND VPWR VPWR sky130_fd_sc_hd__decap_3
XFILLER_75_588 VGND VGND VPWR VPWR sky130_fd_sc_hd__decap_3
XFILLER_46_73 VGND VGND VPWR VPWR sky130_fd_sc_hd__decap_3
XFILLER_62_216 VGND VGND VPWR VPWR sky130_fd_sc_hd__decap_3
XFILLER_90_536 VGND VGND VPWR VPWR sky130_fd_sc_hd__decap_3
XFILLER_43_441 VGND VGND VPWR VPWR sky130_fd_sc_hd__decap_3
XFILLER_55_290 VGND VGND VPWR VPWR sky130_fd_sc_hd__decap_3
XFILLER_62_249 VGND VGND VPWR VPWR sky130_fd_sc_hd__decap_3
XFILLER_15_165 VGND VGND VPWR VPWR sky130_fd_sc_hd__decap_3
XFILLER_15_187 VGND VGND VPWR VPWR sky130_fd_sc_hd__decap_3
XFILLER_31_603 VGND VGND VPWR VPWR sky130_fd_sc_hd__decap_3
XFILLER_30_135 VGND VGND VPWR VPWR sky130_fd_sc_hd__decap_3
XFILLER_62_61 VGND VGND VPWR VPWR sky130_fd_sc_hd__fill_1
XFILLER_30_168 VGND VGND VPWR VPWR sky130_fd_sc_hd__decap_3
XFILLER_62_94 VGND VGND VPWR VPWR sky130_fd_sc_hd__decap_3
XFILLER_7_12 VGND VGND VPWR VPWR sky130_fd_sc_hd__decap_3
XFILLER_11_382 VGND VGND VPWR VPWR sky130_fd_sc_hd__decap_3
XFILLER_7_320 VGND VGND VPWR VPWR sky130_fd_sc_hd__decap_3
XFILLER_7_45 VGND VGND VPWR VPWR sky130_fd_sc_hd__decap_3
XTAP_TAPCELL_ROW_96_1405 VGND VPWR sky130_fd_sc_hd__tapvpwrvgnd_1
XFILLER_7_364 VGND VGND VPWR VPWR sky130_fd_sc_hd__decap_3
XFILLER_109_270 VGND VGND VPWR VPWR sky130_fd_sc_hd__fill_2
XFILLER_109_281 VGND VGND VPWR VPWR sky130_fd_sc_hd__decap_3
X_3340_ _6982_/Q _3340_/B _3340_/C VGND VGND VPWR VPWR _5640_/B sky130_fd_sc_hd__and3_2
XFILLER_112_413 VGND VGND VPWR VPWR sky130_fd_sc_hd__decap_3
XFILLER_112_424 VGND VGND VPWR VPWR sky130_fd_sc_hd__decap_3
XFILLER_97_113 VGND VGND VPWR VPWR sky130_fd_sc_hd__fill_1
XFILLER_97_157 VGND VGND VPWR VPWR sky130_fd_sc_hd__decap_3
X_5010_ _5010_/A _5662_/A _5010_/C _5010_/D VGND VGND VPWR VPWR _5010_/X sky130_fd_sc_hd__or4_2
XFILLER_23_3 VGND VGND VPWR VPWR sky130_fd_sc_hd__decap_3
XFILLER_78_371 VGND VGND VPWR VPWR sky130_fd_sc_hd__decap_3
XFILLER_85_319 VGND VGND VPWR VPWR sky130_fd_sc_hd__decap_3
Xhold1009 _7187_/Q VGND VGND VPWR VPWR _5284_/A0 sky130_fd_sc_hd__dlygate4sd3_1
XFILLER_66_522 VGND VGND VPWR VPWR sky130_fd_sc_hd__decap_3
XFILLER_66_533 VGND VGND VPWR VPWR sky130_fd_sc_hd__decap_3
XFILLER_26_419 VGND VGND VPWR VPWR sky130_fd_sc_hd__fill_1
XFILLER_38_268 VGND VGND VPWR VPWR sky130_fd_sc_hd__decap_3
XFILLER_81_503 VGND VGND VPWR VPWR sky130_fd_sc_hd__fill_1
XFILLER_93_352 VGND VGND VPWR VPWR sky130_fd_sc_hd__decap_3
XFILLER_66_599 VGND VGND VPWR VPWR sky130_fd_sc_hd__decap_3
XFILLER_81_547 VGND VGND VPWR VPWR sky130_fd_sc_hd__decap_3
XFILLER_93_385 VGND VGND VPWR VPWR sky130_fd_sc_hd__decap_3
XFILLER_93_396 VGND VGND VPWR VPWR sky130_fd_sc_hd__decap_3
X_6961_ _6967_/CLK _6961_/D VGND VGND VPWR VPWR _6961_/Q sky130_fd_sc_hd__dfxtp_2
XTAP_TAPCELL_ROW_105_1512 VGND VPWR sky130_fd_sc_hd__tapvpwrvgnd_1
X_6892_ _7404_/CLK _6892_/D VGND VGND VPWR VPWR _6892_/Q sky130_fd_sc_hd__dfxtp_2
XFILLER_21_113 VGND VGND VPWR VPWR sky130_fd_sc_hd__decap_3
XFILLER_61_293 VGND VGND VPWR VPWR sky130_fd_sc_hd__fill_1
XTAP_TAPCELL_ROW_32_631 VGND VPWR sky130_fd_sc_hd__tapvpwrvgnd_1
XFILLER_21_157 VGND VGND VPWR VPWR sky130_fd_sc_hd__decap_3
XTAP_TAPCELL_ROW_60_973 VGND VPWR sky130_fd_sc_hd__tapvpwrvgnd_1
X_4725_ _4969_/B _4720_/X _4723_/X _4724_/X VGND VGND VPWR VPWR _5655_/A sky130_fd_sc_hd__a211o_2
X_7375_ _7394_/CLK _7375_/D _6655_/Y VGND VGND VPWR VPWR _7375_/Q sky130_fd_sc_hd__dfrtp_2
Xhold810 _6929_/Q VGND VGND VPWR VPWR _6929_/D sky130_fd_sc_hd__dlygate4sd3_1
Xhold821 _6956_/Q VGND VGND VPWR VPWR _6956_/D sky130_fd_sc_hd__dlygate4sd3_1
X_4587_ _7287_/Q _4595_/B VGND VGND VPWR VPWR _7287_/D sky130_fd_sc_hd__and2_2
X_3607_ _4295_/B _3607_/B VGND VGND VPWR VPWR _3610_/A sky130_fd_sc_hd__nand2_2
XTAP_TAPCELL_ROW_116_1652 VGND VPWR sky130_fd_sc_hd__tapvpwrvgnd_1
XTAP_TAPCELL_ROW_116_1641 VGND VPWR sky130_fd_sc_hd__tapvpwrvgnd_1
XPHY_EDGE_ROW_2_Left_119 VGND VGND VPWR VPWR sky130_fd_sc_hd__decap_3
Xhold832 _6862_/Q VGND VGND VPWR VPWR _6862_/D sky130_fd_sc_hd__dlygate4sd3_1
Xhold843 _6910_/Q VGND VGND VPWR VPWR _6910_/D sky130_fd_sc_hd__dlygate4sd3_1
Xhold854 _7063_/Q VGND VGND VPWR VPWR _7063_/D sky130_fd_sc_hd__dlygate4sd3_1
Xmax_cap562 _4620_/C VGND VGND VPWR VPWR _4987_/A sky130_fd_sc_hd__clkbuf_2
X_6326_ _6675_/A VGND VGND VPWR VPWR _6326_/Y sky130_fd_sc_hd__inv_2
X_3538_ _3424_/S _3456_/X _4537_/C _3421_/C VGND VGND VPWR VPWR _3544_/B sky130_fd_sc_hd__o2bb2a_2
XFILLER_103_402 VGND VGND VPWR VPWR sky130_fd_sc_hd__decap_3
XFILLER_107_35 VGND VGND VPWR VPWR sky130_fd_sc_hd__decap_3
XFILLER_107_57 VGND VGND VPWR VPWR sky130_fd_sc_hd__decap_3
XFILLER_89_647 VGND VGND VPWR VPWR sky130_fd_sc_hd__decap_3
Xhold865 _7113_/Q VGND VGND VPWR VPWR _7113_/D sky130_fd_sc_hd__dlygate4sd3_1
Xhold876 _7090_/Q VGND VGND VPWR VPWR _7090_/D sky130_fd_sc_hd__dlygate4sd3_1
Xhold887 _7070_/Q VGND VGND VPWR VPWR _7070_/D sky130_fd_sc_hd__dlygate4sd3_1
Xhold898 _7079_/Q VGND VGND VPWR VPWR _7079_/D sky130_fd_sc_hd__dlygate4sd3_1
XFILLER_103_446 VGND VGND VPWR VPWR sky130_fd_sc_hd__fill_2
XFILLER_88_135 VGND VGND VPWR VPWR sky130_fd_sc_hd__decap_3
X_3469_ _3469_/A _3469_/B VGND VGND VPWR VPWR _4537_/C sky130_fd_sc_hd__nor2_2
XFILLER_29_202 VGND VGND VPWR VPWR sky130_fd_sc_hd__decap_3
XFILLER_57_511 VGND VGND VPWR VPWR sky130_fd_sc_hd__fill_2
XFILLER_88_168 VGND VGND VPWR VPWR sky130_fd_sc_hd__fill_2
XTAP_TAPCELL_ROW_4_301 VGND VPWR sky130_fd_sc_hd__tapvpwrvgnd_1
XFILLER_69_393 VGND VGND VPWR VPWR sky130_fd_sc_hd__decap_3
X_5139_ _4677_/B _5138_/X _5092_/C VGND VGND VPWR VPWR _5139_/X sky130_fd_sc_hd__o21a_2
XFILLER_97_691 VGND VGND VPWR VPWR sky130_fd_sc_hd__fill_1
XFILLER_29_257 VGND VGND VPWR VPWR sky130_fd_sc_hd__decap_3
XFILLER_72_514 VGND VGND VPWR VPWR sky130_fd_sc_hd__decap_3
XFILLER_84_341 VGND VGND VPWR VPWR sky130_fd_sc_hd__decap_3
XFILLER_83_49 VGND VGND VPWR VPWR sky130_fd_sc_hd__fill_1
XFILLER_84_374 VGND VGND VPWR VPWR sky130_fd_sc_hd__decap_3
XFILLER_16_21 VGND VGND VPWR VPWR sky130_fd_sc_hd__decap_3
XFILLER_16_32 VGND VGND VPWR VPWR sky130_fd_sc_hd__decap_3
XFILLER_25_452 VGND VGND VPWR VPWR sky130_fd_sc_hd__decap_3
XFILLER_37_290 VGND VGND VPWR VPWR sky130_fd_sc_hd__decap_3
XFILLER_44_249 VGND VGND VPWR VPWR sky130_fd_sc_hd__decap_3
XFILLER_72_569 VGND VGND VPWR VPWR sky130_fd_sc_hd__decap_3
XFILLER_16_54 VGND VGND VPWR VPWR sky130_fd_sc_hd__decap_3
XFILLER_52_271 VGND VGND VPWR VPWR sky130_fd_sc_hd__decap_3
XTAP_TAPCELL_ROW_80_1217 VGND VPWR sky130_fd_sc_hd__tapvpwrvgnd_1
XTAP_TAPCELL_ROW_80_1206 VGND VPWR sky130_fd_sc_hd__tapvpwrvgnd_1
XFILLER_12_113 VGND VGND VPWR VPWR sky130_fd_sc_hd__decap_3
XFILLER_40_433 VGND VGND VPWR VPWR sky130_fd_sc_hd__fill_1
XFILLER_32_20 VGND VGND VPWR VPWR sky130_fd_sc_hd__decap_3
XFILLER_40_455 VGND VGND VPWR VPWR sky130_fd_sc_hd__decap_3
XFILLER_40_477 VGND VGND VPWR VPWR sky130_fd_sc_hd__decap_3
XFILLER_8_106 VGND VGND VPWR VPWR sky130_fd_sc_hd__decap_3
XFILLER_32_42 VGND VGND VPWR VPWR sky130_fd_sc_hd__decap_3
XFILLER_4_312 VGND VGND VPWR VPWR sky130_fd_sc_hd__decap_3
XTAP_TAPCELL_ROW_10_369 VGND VPWR sky130_fd_sc_hd__tapvpwrvgnd_1
XFILLER_106_240 VGND VGND VPWR VPWR sky130_fd_sc_hd__decap_3
XFILLER_4_345 VGND VGND VPWR VPWR sky130_fd_sc_hd__decap_3
XFILLER_106_262 VGND VGND VPWR VPWR sky130_fd_sc_hd__decap_3
XTAP_TAPCELL_ROW_91_1346 VGND VPWR sky130_fd_sc_hd__tapvpwrvgnd_1
XFILLER_79_146 VGND VGND VPWR VPWR sky130_fd_sc_hd__decap_3
XFILLER_95_606 VGND VGND VPWR VPWR sky130_fd_sc_hd__fill_2
XFILLER_95_617 VGND VGND VPWR VPWR sky130_fd_sc_hd__decap_3
XFILLER_48_522 VGND VGND VPWR VPWR sky130_fd_sc_hd__fill_2
XFILLER_48_533 VGND VGND VPWR VPWR sky130_fd_sc_hd__fill_2
XFILLER_75_330 VGND VGND VPWR VPWR sky130_fd_sc_hd__decap_3
XFILLER_57_72 VGND VGND VPWR VPWR sky130_fd_sc_hd__decap_3
XFILLER_35_216 VGND VGND VPWR VPWR sky130_fd_sc_hd__decap_3
XFILLER_63_525 VGND VGND VPWR VPWR sky130_fd_sc_hd__decap_3
XFILLER_75_396 VGND VGND VPWR VPWR sky130_fd_sc_hd__decap_3
XFILLER_16_430 VGND VGND VPWR VPWR sky130_fd_sc_hd__decap_3
XFILLER_63_558 VGND VGND VPWR VPWR sky130_fd_sc_hd__fill_2
XFILLER_90_333 VGND VGND VPWR VPWR sky130_fd_sc_hd__decap_3
XFILLER_43_260 VGND VGND VPWR VPWR sky130_fd_sc_hd__decap_3
XFILLER_73_60 VGND VGND VPWR VPWR sky130_fd_sc_hd__decap_3
XFILLER_90_377 VGND VGND VPWR VPWR sky130_fd_sc_hd__decap_3
XFILLER_90_399 VGND VGND VPWR VPWR sky130_fd_sc_hd__decap_3
XTAP_TAPCELL_ROW_18_469 VGND VPWR sky130_fd_sc_hd__tapvpwrvgnd_1
XFILLER_43_293 VGND VGND VPWR VPWR sky130_fd_sc_hd__decap_3
XFILLER_71_591 VGND VGND VPWR VPWR sky130_fd_sc_hd__fill_1
XFILLER_73_93 VGND VGND VPWR VPWR sky130_fd_sc_hd__decap_3
XFILLER_92_6 VGND VGND VPWR VPWR sky130_fd_sc_hd__fill_2
XTAP_TAPCELL_ROW_100_1453 VGND VPWR sky130_fd_sc_hd__tapvpwrvgnd_1
XFILLER_31_488 VGND VGND VPWR VPWR sky130_fd_sc_hd__decap_3
X_4510_ _4510_/A0 _7292_/Q _4510_/S VGND VGND VPWR VPWR _7324_/D sky130_fd_sc_hd__mux2_2
XFILLER_7_172 VGND VGND VPWR VPWR sky130_fd_sc_hd__decap_3
X_4441_ _4813_/B _4441_/B VGND VGND VPWR VPWR _4827_/A sky130_fd_sc_hd__nand2_2
X_7160_ clkload8/A _7160_/D _6440_/Y VGND VGND VPWR VPWR _7160_/Q sky130_fd_sc_hd__dfrtp_2
XPHY_EDGE_ROW_9_Right_9 VGND VGND VPWR VPWR sky130_fd_sc_hd__decap_3
X_4372_ _4372_/A _4627_/A VGND VGND VPWR VPWR _5018_/A sky130_fd_sc_hd__or2_2
X_7091_ clkload5/A _7091_/D _6371_/Y VGND VGND VPWR VPWR _7091_/Q sky130_fd_sc_hd__dfrtp_2
X_3323_ _3561_/A _3519_/B _5294_/A _5129_/B VGND VGND VPWR VPWR _3323_/X sky130_fd_sc_hd__a31o_2
XFILLER_98_444 VGND VGND VPWR VPWR sky130_fd_sc_hd__decap_3
XFILLER_98_433 VGND VGND VPWR VPWR sky130_fd_sc_hd__decap_3
XFILLER_100_416 VGND VGND VPWR VPWR sky130_fd_sc_hd__decap_3
XFILLER_112_265 VGND VGND VPWR VPWR sky130_fd_sc_hd__decap_3
XFILLER_85_105 VGND VGND VPWR VPWR sky130_fd_sc_hd__decap_3
XTAP_TAPCELL_ROW_111_1582 VGND VPWR sky130_fd_sc_hd__tapvpwrvgnd_1
XPHY_EDGE_ROW_107_Right_107 VGND VGND VPWR VPWR sky130_fd_sc_hd__decap_3
XFILLER_98_477 VGND VGND VPWR VPWR sky130_fd_sc_hd__decap_3
XFILLER_112_298 VGND VGND VPWR VPWR sky130_fd_sc_hd__fill_1
XFILLER_85_127 VGND VGND VPWR VPWR sky130_fd_sc_hd__decap_3
XFILLER_66_341 VGND VGND VPWR VPWR sky130_fd_sc_hd__decap_3
XFILLER_66_396 VGND VGND VPWR VPWR sky130_fd_sc_hd__decap_3
XFILLER_81_300 VGND VGND VPWR VPWR sky130_fd_sc_hd__decap_3
XTAP_TAPCELL_ROW_37_701 VGND VPWR sky130_fd_sc_hd__tapvpwrvgnd_1
XFILLER_19_290 VGND VGND VPWR VPWR sky130_fd_sc_hd__decap_3
XFILLER_26_249 VGND VGND VPWR VPWR sky130_fd_sc_hd__decap_3
XFILLER_81_355 VGND VGND VPWR VPWR sky130_fd_sc_hd__decap_3
X_6944_ _7198_/CLK _6944_/D VGND VGND VPWR VPWR _6944_/Q sky130_fd_sc_hd__dfxtp_2
XFILLER_34_271 VGND VGND VPWR VPWR sky130_fd_sc_hd__decap_3
X_6875_ _7383_/CLK _6875_/D VGND VGND VPWR VPWR _6875_/Q sky130_fd_sc_hd__dfxtp_2
XFILLER_10_606 VGND VGND VPWR VPWR sky130_fd_sc_hd__fill_2
X_4708_ _7001_/Q _4825_/B VGND VGND VPWR VPWR _4826_/A sky130_fd_sc_hd__and2_2
X_5688_ _7350_/Q hold968/X _5708_/S VGND VGND VPWR VPWR _5688_/X sky130_fd_sc_hd__mux2_2
X_4639_ _4639_/A _4948_/B VGND VGND VPWR VPWR _4918_/A sky130_fd_sc_hd__or2_2
XFILLER_116_582 VGND VGND VPWR VPWR sky130_fd_sc_hd__decap_3
XFILLER_89_411 VGND VGND VPWR VPWR sky130_fd_sc_hd__decap_3
X_7358_ _7401_/CLK _7358_/D _6638_/Y VGND VGND VPWR VPWR _7358_/Q sky130_fd_sc_hd__dfrtp_2
Xhold640 _6739_/Q VGND VGND VPWR VPWR _6739_/D sky130_fd_sc_hd__dlygate4sd3_1
Xhold651 _6762_/Q VGND VGND VPWR VPWR _6762_/D sky130_fd_sc_hd__dlygate4sd3_1
Xhold662 _6742_/Q VGND VGND VPWR VPWR _6742_/D sky130_fd_sc_hd__dlygate4sd3_1
XFILLER_103_243 VGND VGND VPWR VPWR sky130_fd_sc_hd__decap_3
XFILLER_89_444 VGND VGND VPWR VPWR sky130_fd_sc_hd__decap_3
XFILLER_89_455 VGND VGND VPWR VPWR sky130_fd_sc_hd__decap_3
X_7289_ _7381_/CLK _7289_/D _6569_/Y VGND VGND VPWR VPWR _7289_/Q sky130_fd_sc_hd__dfrtp_2
Xhold673 _6722_/Q VGND VGND VPWR VPWR _6722_/D sky130_fd_sc_hd__dlygate4sd3_1
Xhold684 _6817_/Q VGND VGND VPWR VPWR _6817_/D sky130_fd_sc_hd__dlygate4sd3_1
Xhold695 _6861_/Q VGND VGND VPWR VPWR _6861_/D sky130_fd_sc_hd__dlygate4sd3_1
X_6309_ _6672_/A VGND VGND VPWR VPWR _6309_/Y sky130_fd_sc_hd__inv_2
XFILLER_77_617 VGND VGND VPWR VPWR sky130_fd_sc_hd__fill_1
XFILLER_89_488 VGND VGND VPWR VPWR sky130_fd_sc_hd__decap_3
XFILLER_103_287 VGND VGND VPWR VPWR sky130_fd_sc_hd__decap_3
XFILLER_57_352 VGND VGND VPWR VPWR sky130_fd_sc_hd__decap_3
XFILLER_69_190 VGND VGND VPWR VPWR sky130_fd_sc_hd__decap_3
XFILLER_94_59 VGND VGND VPWR VPWR sky130_fd_sc_hd__decap_3
XFILLER_17_205 VGND VGND VPWR VPWR sky130_fd_sc_hd__decap_3
XFILLER_27_31 VGND VGND VPWR VPWR sky130_fd_sc_hd__decap_3
XFILLER_27_53 VGND VGND VPWR VPWR sky130_fd_sc_hd__decap_3
XFILLER_57_396 VGND VGND VPWR VPWR sky130_fd_sc_hd__decap_3
XFILLER_91_119 VGND VGND VPWR VPWR sky130_fd_sc_hd__decap_3
XFILLER_27_75 VGND VGND VPWR VPWR sky130_fd_sc_hd__decap_3
XFILLER_45_558 VGND VGND VPWR VPWR sky130_fd_sc_hd__fill_2
XFILLER_25_260 VGND VGND VPWR VPWR sky130_fd_sc_hd__decap_3
XFILLER_32_219 VGND VGND VPWR VPWR sky130_fd_sc_hd__decap_3
XFILLER_60_539 VGND VGND VPWR VPWR sky130_fd_sc_hd__decap_3
XFILLER_72_377 VGND VGND VPWR VPWR sky130_fd_sc_hd__fill_1
XFILLER_13_422 VGND VGND VPWR VPWR sky130_fd_sc_hd__decap_3
XFILLER_25_293 VGND VGND VPWR VPWR sky130_fd_sc_hd__decap_3
XTAP_TAPCELL_ROW_15_428 VGND VPWR sky130_fd_sc_hd__tapvpwrvgnd_1
XFILLER_40_241 VGND VGND VPWR VPWR sky130_fd_sc_hd__decap_3
XFILLER_43_63 VGND VGND VPWR VPWR sky130_fd_sc_hd__decap_3
XFILLER_40_274 VGND VGND VPWR VPWR sky130_fd_sc_hd__decap_3
XFILLER_114_519 VGND VGND VPWR VPWR sky130_fd_sc_hd__fill_2
XFILLER_4_164 VGND VGND VPWR VPWR sky130_fd_sc_hd__decap_3
XFILLER_4_197 VGND VGND VPWR VPWR sky130_fd_sc_hd__decap_3
XFILLER_4_57 VGND VGND VPWR VPWR sky130_fd_sc_hd__decap_3
XFILLER_67_105 VGND VGND VPWR VPWR sky130_fd_sc_hd__decap_3
XFILLER_67_116 VGND VGND VPWR VPWR sky130_fd_sc_hd__decap_3
XFILLER_68_82 VGND VGND VPWR VPWR sky130_fd_sc_hd__fill_2
XFILLER_95_447 VGND VGND VPWR VPWR sky130_fd_sc_hd__fill_1
XFILLER_95_458 VGND VGND VPWR VPWR sky130_fd_sc_hd__decap_3
XFILLER_48_330 VGND VGND VPWR VPWR sky130_fd_sc_hd__decap_3
XFILLER_82_108 VGND VGND VPWR VPWR sky130_fd_sc_hd__decap_3
XFILLER_63_311 VGND VGND VPWR VPWR sky130_fd_sc_hd__decap_3
XFILLER_91_620 VGND VGND VPWR VPWR sky130_fd_sc_hd__decap_3
XFILLER_36_569 VGND VGND VPWR VPWR sky130_fd_sc_hd__fill_2
XFILLER_63_355 VGND VGND VPWR VPWR sky130_fd_sc_hd__decap_3
XFILLER_75_193 VGND VGND VPWR VPWR sky130_fd_sc_hd__decap_3
XFILLER_90_141 VGND VGND VPWR VPWR sky130_fd_sc_hd__fill_2
XFILLER_91_642 VGND VGND VPWR VPWR sky130_fd_sc_hd__fill_1
Xplace322 _4356_/A2 VGND VGND VPWR VPWR _4418_/A2 sky130_fd_sc_hd__buf_2
Xplace311 _3522_/Y VGND VGND VPWR VPWR _5020_/A sky130_fd_sc_hd__buf_2
Xplace300 _3889_/A2 VGND VGND VPWR VPWR _3882_/A2 sky130_fd_sc_hd__buf_2
XFILLER_63_388 VGND VGND VPWR VPWR sky130_fd_sc_hd__decap_3
Xplace355 _4417_/A2 VGND VGND VPWR VPWR _5028_/S sky130_fd_sc_hd__buf_2
Xplace344 _3604_/B VGND VGND VPWR VPWR _4891_/A1 sky130_fd_sc_hd__buf_2
Xplace333 _4351_/B1 VGND VGND VPWR VPWR _4195_/A2 sky130_fd_sc_hd__buf_2
X_4990_ _4620_/A _4989_/X _4374_/X VGND VGND VPWR VPWR _5004_/B sky130_fd_sc_hd__o21ai_2
XFILLER_16_271 VGND VGND VPWR VPWR sky130_fd_sc_hd__decap_3
XFILLER_51_539 VGND VGND VPWR VPWR sky130_fd_sc_hd__decap_3
XFILLER_63_399 VGND VGND VPWR VPWR sky130_fd_sc_hd__decap_3
Xplace388 _5217_/B VGND VGND VPWR VPWR _5225_/B sky130_fd_sc_hd__buf_2
Xplace377 _3339_/Y VGND VGND VPWR VPWR _3757_/S sky130_fd_sc_hd__buf_2
Xplace366 _4305_/B VGND VGND VPWR VPWR _4265_/B sky130_fd_sc_hd__buf_2
X_3941_ _7369_/Q _4484_/A0 _3945_/S VGND VGND VPWR VPWR _7369_/D sky130_fd_sc_hd__mux2_2
Xplace399 _5340_/S VGND VGND VPWR VPWR _5360_/S sky130_fd_sc_hd__buf_2
X_6660_ _6660_/A VGND VGND VPWR VPWR _6660_/Y sky130_fd_sc_hd__inv_2
X_3872_ _6921_/Q _3926_/A2 _3906_/B1 _6695_/Q _3871_/X VGND VGND VPWR VPWR _3872_/X
+ sky130_fd_sc_hd__a221o_2
XFILLER_31_274 VGND VGND VPWR VPWR sky130_fd_sc_hd__fill_2
X_6591_ _6634_/A VGND VGND VPWR VPWR _6591_/Y sky130_fd_sc_hd__inv_2
X_5611_ _5611_/A _5611_/B VGND VGND VPWR VPWR _7022_/D sky130_fd_sc_hd__and2_2
XFILLER_105_508 VGND VGND VPWR VPWR sky130_fd_sc_hd__decap_3
X_7212_ _7340_/CLK _7212_/D _6492_/Y VGND VGND VPWR VPWR _7212_/Q sky130_fd_sc_hd__dfrtp_2
X_4424_ _4425_/A _4425_/C _4649_/B VGND VGND VPWR VPWR _4446_/A sky130_fd_sc_hd__a21oi_2
XTAP_TAPCELL_ROW_113_1611 VGND VPWR sky130_fd_sc_hd__tapvpwrvgnd_1
X_7143_ _7338_/CLK _7143_/D _6423_/Y VGND VGND VPWR VPWR _7143_/Q sky130_fd_sc_hd__dfrtp_2
X_4355_ _4355_/A _4355_/B VGND VGND VPWR VPWR _4355_/X sky130_fd_sc_hd__or2_2
XPHY_EDGE_ROW_92_Left_209 VGND VGND VPWR VPWR sky130_fd_sc_hd__decap_3
XFILLER_98_241 VGND VGND VPWR VPWR sky130_fd_sc_hd__decap_3
XFILLER_98_230 VGND VGND VPWR VPWR sky130_fd_sc_hd__fill_2
XFILLER_48_19 VGND VGND VPWR VPWR sky130_fd_sc_hd__decap_3
XFILLER_59_617 VGND VGND VPWR VPWR sky130_fd_sc_hd__fill_2
X_7074_ _7330_/CLK _7074_/D _6354_/Y VGND VGND VPWR VPWR _7074_/Q sky130_fd_sc_hd__dfrtp_2
X_3306_ _6982_/Q _3328_/A _6981_/D _4696_/B _3340_/B VGND VGND VPWR VPWR _3378_/A
+ sky130_fd_sc_hd__o221a_2
XFILLER_98_274 VGND VGND VPWR VPWR sky130_fd_sc_hd__decap_3
XFILLER_113_585 VGND VGND VPWR VPWR sky130_fd_sc_hd__decap_3
XFILLER_58_127 VGND VGND VPWR VPWR sky130_fd_sc_hd__fill_1
XFILLER_59_639 VGND VGND VPWR VPWR sky130_fd_sc_hd__decap_3
XFILLER_86_436 VGND VGND VPWR VPWR sky130_fd_sc_hd__decap_3
X_4286_ _4286_/A _4286_/B VGND VGND VPWR VPWR _4288_/C sky130_fd_sc_hd__or2_2
XFILLER_98_296 VGND VGND VPWR VPWR sky130_fd_sc_hd__decap_3
XFILLER_100_246 VGND VGND VPWR VPWR sky130_fd_sc_hd__decap_3
XFILLER_73_108 VGND VGND VPWR VPWR sky130_fd_sc_hd__decap_3
XFILLER_104_47 VGND VGND VPWR VPWR sky130_fd_sc_hd__decap_3
XFILLER_27_514 VGND VGND VPWR VPWR sky130_fd_sc_hd__fill_2
XFILLER_39_363 VGND VGND VPWR VPWR sky130_fd_sc_hd__decap_3
XFILLER_66_171 VGND VGND VPWR VPWR sky130_fd_sc_hd__decap_3
XFILLER_67_683 VGND VGND VPWR VPWR sky130_fd_sc_hd__decap_3
XFILLER_94_480 VGND VGND VPWR VPWR sky130_fd_sc_hd__decap_3
XFILLER_54_344 VGND VGND VPWR VPWR sky130_fd_sc_hd__decap_3
XFILLER_66_182 VGND VGND VPWR VPWR sky130_fd_sc_hd__decap_3
XFILLER_82_664 VGND VGND VPWR VPWR sky130_fd_sc_hd__decap_3
XFILLER_54_388 VGND VGND VPWR VPWR sky130_fd_sc_hd__decap_3
XFILLER_81_163 VGND VGND VPWR VPWR sky130_fd_sc_hd__decap_3
X_6927_ _7383_/CLK _6927_/D VGND VGND VPWR VPWR _6927_/Q sky130_fd_sc_hd__dfxtp_2
XFILLER_22_230 VGND VGND VPWR VPWR sky130_fd_sc_hd__decap_3
Xfanout23 _6570_/A VGND VGND VPWR VPWR _6532_/A sky130_fd_sc_hd__buf_2
Xfanout34 fanout38/X VGND VGND VPWR VPWR _6637_/A sky130_fd_sc_hd__buf_2
Xfanout45 _6643_/A VGND VGND VPWR VPWR _6611_/A sky130_fd_sc_hd__clkbuf_2
Xfanout56 _6686_/A VGND VGND VPWR VPWR _6684_/A sky130_fd_sc_hd__buf_2
X_6858_ _6909_/CLK _6858_/D VGND VGND VPWR VPWR _6858_/Q sky130_fd_sc_hd__dfxtp_2
XFILLER_13_11 VGND VGND VPWR VPWR sky130_fd_sc_hd__decap_3
XFILLER_22_274 VGND VGND VPWR VPWR sky130_fd_sc_hd__decap_3
Xfanout67 _6619_/A VGND VGND VPWR VPWR _6558_/A sky130_fd_sc_hd__clkdlybuf4s25_1
XTAP_TAPCELL_ROW_40_729 VGND VPWR sky130_fd_sc_hd__tapvpwrvgnd_1
XFILLER_13_44 VGND VGND VPWR VPWR sky130_fd_sc_hd__decap_3
XFILLER_13_66 VGND VGND VPWR VPWR sky130_fd_sc_hd__decap_3
XFILLER_22_296 VGND VGND VPWR VPWR sky130_fd_sc_hd__decap_3
X_6789_ clkload1/A _6789_/D VGND VGND VPWR VPWR _6789_/Q sky130_fd_sc_hd__dfxtp_2
XFILLER_108_324 VGND VGND VPWR VPWR sky130_fd_sc_hd__decap_3
XFILLER_13_88 VGND VGND VPWR VPWR sky130_fd_sc_hd__fill_2
XFILLER_89_15 VGND VGND VPWR VPWR sky130_fd_sc_hd__decap_3
XFILLER_108_357 VGND VGND VPWR VPWR sky130_fd_sc_hd__decap_3
XFILLER_108_368 VGND VGND VPWR VPWR sky130_fd_sc_hd__decap_3
XFILLER_89_37 VGND VGND VPWR VPWR sky130_fd_sc_hd__decap_3
XTAP_TAPCELL_ROW_20_497 VGND VPWR sky130_fd_sc_hd__tapvpwrvgnd_1
XTAP_TAPCELL_ROW_20_486 VGND VPWR sky130_fd_sc_hd__tapvpwrvgnd_1
XTAP_TAPCELL_ROW_75_1149 VGND VPWR sky130_fd_sc_hd__tapvpwrvgnd_1
XFILLER_104_541 VGND VGND VPWR VPWR sky130_fd_sc_hd__decap_3
XFILLER_77_414 VGND VGND VPWR VPWR sky130_fd_sc_hd__decap_3
XFILLER_89_252 VGND VGND VPWR VPWR sky130_fd_sc_hd__fill_1
XFILLER_49_116 VGND VGND VPWR VPWR sky130_fd_sc_hd__decap_3
XFILLER_77_447 VGND VGND VPWR VPWR sky130_fd_sc_hd__fill_1
XFILLER_38_41 VGND VGND VPWR VPWR sky130_fd_sc_hd__decap_3
XFILLER_38_63 VGND VGND VPWR VPWR sky130_fd_sc_hd__decap_3
XFILLER_49_149 VGND VGND VPWR VPWR sky130_fd_sc_hd__decap_3
XFILLER_77_469 VGND VGND VPWR VPWR sky130_fd_sc_hd__decap_3
XFILLER_38_85 VGND VGND VPWR VPWR sky130_fd_sc_hd__decap_3
XFILLER_73_620 VGND VGND VPWR VPWR sky130_fd_sc_hd__fill_2
XFILLER_85_480 VGND VGND VPWR VPWR sky130_fd_sc_hd__decap_3
Xhold1170 _7180_/Q VGND VGND VPWR VPWR _5300_/A0 sky130_fd_sc_hd__dlygate4sd3_1
XTAP_TAPCELL_ROW_48_829 VGND VPWR sky130_fd_sc_hd__tapvpwrvgnd_1
Xhold1181 _7124_/Q VGND VGND VPWR VPWR _5419_/A0 sky130_fd_sc_hd__dlygate4sd3_1
Xhold1192 _7252_/Q VGND VGND VPWR VPWR _5132_/A0 sky130_fd_sc_hd__dlygate4sd3_1
XFILLER_45_355 VGND VGND VPWR VPWR sky130_fd_sc_hd__fill_1
XFILLER_72_141 VGND VGND VPWR VPWR sky130_fd_sc_hd__decap_3
XFILLER_72_163 VGND VGND VPWR VPWR sky130_fd_sc_hd__decap_3
XTAP_TAPCELL_ROW_86_1289 VGND VPWR sky130_fd_sc_hd__tapvpwrvgnd_1
XTAP_TAPCELL_ROW_86_1278 VGND VPWR sky130_fd_sc_hd__tapvpwrvgnd_1
XFILLER_45_399 VGND VGND VPWR VPWR sky130_fd_sc_hd__decap_3
XFILLER_54_73 VGND VGND VPWR VPWR sky130_fd_sc_hd__decap_3
XFILLER_60_325 VGND VGND VPWR VPWR sky130_fd_sc_hd__decap_3
XFILLER_72_174 VGND VGND VPWR VPWR sky130_fd_sc_hd__decap_3
XTAP_TAPCELL_ROW_28_586 VGND VPWR sky130_fd_sc_hd__tapvpwrvgnd_1
XFILLER_60_358 VGND VGND VPWR VPWR sky130_fd_sc_hd__decap_3
XFILLER_13_274 VGND VGND VPWR VPWR sky130_fd_sc_hd__decap_3
XFILLER_9_234 VGND VGND VPWR VPWR sky130_fd_sc_hd__decap_3
XFILLER_9_223 VGND VGND VPWR VPWR sky130_fd_sc_hd__fill_1
XFILLER_9_267 VGND VGND VPWR VPWR sky130_fd_sc_hd__decap_3
XFILLER_70_72 VGND VGND VPWR VPWR sky130_fd_sc_hd__fill_2
Xclkload15 _7390_/CLK VGND VGND VPWR VPWR clkload15/X sky130_fd_sc_hd__clkbuf_8
Xclkload26 _7362_/CLK VGND VGND VPWR VPWR clkload26/X sky130_fd_sc_hd__clkbuf_1
XFILLER_9_278 VGND VGND VPWR VPWR sky130_fd_sc_hd__fill_2
Xclkload37 _7371_/CLK VGND VGND VPWR VPWR clkload37/X sky130_fd_sc_hd__clkbuf_1
XFILLER_55_6 VGND VGND VPWR VPWR sky130_fd_sc_hd__decap_3
XFILLER_5_473 VGND VGND VPWR VPWR sky130_fd_sc_hd__fill_1
XFILLER_114_349 VGND VGND VPWR VPWR sky130_fd_sc_hd__decap_3
X_4140_ _4117_/Y _4124_/B _4890_/B _4886_/A VGND VGND VPWR VPWR _4140_/X sky130_fd_sc_hd__a2bb2o_2
XFILLER_110_533 VGND VGND VPWR VPWR sky130_fd_sc_hd__decap_3
XFILLER_95_211 VGND VGND VPWR VPWR sky130_fd_sc_hd__fill_1
XFILLER_110_566 VGND VGND VPWR VPWR sky130_fd_sc_hd__decap_3
X_4071_ _7307_/Q _4488_/S _4437_/B1 _7371_/Q _4429_/C1 VGND VGND VPWR VPWR _4071_/X
+ sky130_fd_sc_hd__a221o_2
XFILLER_76_480 VGND VGND VPWR VPWR sky130_fd_sc_hd__decap_3
XFILLER_95_80 VGND VGND VPWR VPWR sky130_fd_sc_hd__decap_3
XFILLER_36_333 VGND VGND VPWR VPWR sky130_fd_sc_hd__decap_3
XFILLER_36_344 VGND VGND VPWR VPWR sky130_fd_sc_hd__fill_2
XFILLER_36_377 VGND VGND VPWR VPWR sky130_fd_sc_hd__decap_3
XFILLER_91_461 VGND VGND VPWR VPWR sky130_fd_sc_hd__decap_3
XFILLER_51_314 VGND VGND VPWR VPWR sky130_fd_sc_hd__decap_3
XFILLER_63_174 VGND VGND VPWR VPWR sky130_fd_sc_hd__decap_3
XFILLER_91_483 VGND VGND VPWR VPWR sky130_fd_sc_hd__fill_1
X_4973_ _5595_/B _4973_/B _3813_/Y VGND VGND VPWR VPWR _4973_/X sky130_fd_sc_hd__or3b_2
XFILLER_51_358 VGND VGND VPWR VPWR sky130_fd_sc_hd__fill_1
X_6712_ _7404_/CLK _6712_/D VGND VGND VPWR VPWR _6712_/Q sky130_fd_sc_hd__dfxtp_2
X_3924_ _3924_/A1 _5151_/A _3923_/X VGND VGND VPWR VPWR _7376_/D sky130_fd_sc_hd__o21a_2
XFILLER_32_583 VGND VGND VPWR VPWR sky130_fd_sc_hd__decap_3
X_6643_ _6643_/A VGND VGND VPWR VPWR _6643_/Y sky130_fd_sc_hd__inv_2
Xclkload9 clkload9/A VGND VGND VPWR VPWR clkload9/Y sky130_fd_sc_hd__clkinv_8
X_3855_ _3728_/Y _3847_/X _3849_/X _3714_/X _3854_/X VGND VGND VPWR VPWR _3855_/X
+ sky130_fd_sc_hd__a221o_2
X_6574_ _6604_/A VGND VGND VPWR VPWR _6574_/Y sky130_fd_sc_hd__inv_2
X_3786_ _6751_/Q _3661_/X _3890_/B1 _6733_/Q VGND VGND VPWR VPWR _3786_/X sky130_fd_sc_hd__a22o_2
XFILLER_105_327 VGND VGND VPWR VPWR sky130_fd_sc_hd__decap_3
Xoutput520 _3339_/C1 VGND VGND VPWR VPWR instruction_out[6] sky130_fd_sc_hd__clkdlybuf4s25_1
Xoutput553 _6984_/Q VGND VGND VPWR VPWR pc_out[7] sky130_fd_sc_hd__clkdlybuf4s25_1
Xoutput542 _7003_/Q VGND VGND VPWR VPWR pc_out[26] sky130_fd_sc_hd__clkdlybuf4s25_1
Xoutput531 _6993_/Q VGND VGND VPWR VPWR pc_out[16] sky130_fd_sc_hd__clkdlybuf4s25_1
X_4407_ _7370_/Q _4435_/B1 _4436_/B1 _7178_/Q _4406_/X VGND VGND VPWR VPWR _4407_/X
+ sky130_fd_sc_hd__a221o_2
XFILLER_99_561 VGND VGND VPWR VPWR sky130_fd_sc_hd__decap_3
XFILLER_101_500 VGND VGND VPWR VPWR sky130_fd_sc_hd__decap_3
XFILLER_101_511 VGND VGND VPWR VPWR sky130_fd_sc_hd__decap_3
XFILLER_113_382 VGND VGND VPWR VPWR sky130_fd_sc_hd__decap_3
XFILLER_59_414 VGND VGND VPWR VPWR sky130_fd_sc_hd__decap_3
XFILLER_59_447 VGND VGND VPWR VPWR sky130_fd_sc_hd__fill_1
XFILLER_86_200 VGND VGND VPWR VPWR sky130_fd_sc_hd__decap_3
X_7126_ clkload4/A _7126_/D _6406_/Y VGND VGND VPWR VPWR _7126_/Q sky130_fd_sc_hd__dfrtp_2
X_4338_ _7319_/Q _3977_/S _4338_/B1 _7351_/Q _3556_/A VGND VGND VPWR VPWR _4338_/X
+ sky130_fd_sc_hd__a221o_2
XFILLER_115_57 VGND VGND VPWR VPWR sky130_fd_sc_hd__decap_3
XFILLER_59_458 VGND VGND VPWR VPWR sky130_fd_sc_hd__fill_1
XFILLER_86_233 VGND VGND VPWR VPWR sky130_fd_sc_hd__decap_3
X_7057_ clkload5/A _7057_/D _6337_/Y VGND VGND VPWR VPWR _7057_/Q sky130_fd_sc_hd__dfrtp_2
X_4269_ _7230_/Q _4469_/A3 _4510_/S _7043_/Q _4268_/X VGND VGND VPWR VPWR _4271_/C
+ sky130_fd_sc_hd__a221o_2
XFILLER_46_108 VGND VGND VPWR VPWR sky130_fd_sc_hd__decap_3
XFILLER_74_428 VGND VGND VPWR VPWR sky130_fd_sc_hd__decap_3
XFILLER_27_322 VGND VGND VPWR VPWR sky130_fd_sc_hd__decap_3
XFILLER_27_355 VGND VGND VPWR VPWR sky130_fd_sc_hd__decap_3
XFILLER_54_141 VGND VGND VPWR VPWR sky130_fd_sc_hd__decap_3
XFILLER_70_601 VGND VGND VPWR VPWR sky130_fd_sc_hd__decap_3
XFILLER_82_472 VGND VGND VPWR VPWR sky130_fd_sc_hd__decap_3
XFILLER_54_174 VGND VGND VPWR VPWR sky130_fd_sc_hd__decap_3
XFILLER_70_645 VGND VGND VPWR VPWR sky130_fd_sc_hd__decap_3
XFILLER_82_483 VGND VGND VPWR VPWR sky130_fd_sc_hd__decap_3
XFILLER_82_494 VGND VGND VPWR VPWR sky130_fd_sc_hd__decap_3
XFILLER_91_16 VGND VGND VPWR VPWR sky130_fd_sc_hd__decap_3
XTAP_TAPCELL_ROW_25_556 VGND VPWR sky130_fd_sc_hd__tapvpwrvgnd_1
XFILLER_23_561 VGND VGND VPWR VPWR sky130_fd_sc_hd__decap_3
XTAP_TAPCELL_ROW_53_887 VGND VPWR sky130_fd_sc_hd__tapvpwrvgnd_1
XFILLER_10_211 VGND VGND VPWR VPWR sky130_fd_sc_hd__decap_3
XFILLER_10_244 VGND VGND VPWR VPWR sky130_fd_sc_hd__decap_3
XFILLER_24_98 VGND VGND VPWR VPWR sky130_fd_sc_hd__decap_3
XFILLER_109_611 VGND VGND VPWR VPWR sky130_fd_sc_hd__decap_3
XFILLER_10_266 VGND VGND VPWR VPWR sky130_fd_sc_hd__decap_3
XFILLER_6_215 VGND VGND VPWR VPWR sky130_fd_sc_hd__decap_3
XFILLER_109_666 VGND VGND VPWR VPWR sky130_fd_sc_hd__decap_3
XFILLER_40_53 VGND VGND VPWR VPWR sky130_fd_sc_hd__decap_3
XFILLER_6_248 VGND VGND VPWR VPWR sky130_fd_sc_hd__decap_3
XFILLER_108_176 VGND VGND VPWR VPWR sky130_fd_sc_hd__decap_3
XFILLER_40_75 VGND VGND VPWR VPWR sky130_fd_sc_hd__decap_3
XFILLER_2_421 VGND VGND VPWR VPWR sky130_fd_sc_hd__fill_1
XFILLER_2_432 VGND VGND VPWR VPWR sky130_fd_sc_hd__fill_1
XFILLER_104_360 VGND VGND VPWR VPWR sky130_fd_sc_hd__decap_3
XFILLER_104_382 VGND VGND VPWR VPWR sky130_fd_sc_hd__decap_3
XFILLER_49_51 VGND VGND VPWR VPWR sky130_fd_sc_hd__decap_3
XFILLER_77_255 VGND VGND VPWR VPWR sky130_fd_sc_hd__fill_2
XFILLER_37_119 VGND VGND VPWR VPWR sky130_fd_sc_hd__decap_3
XFILLER_65_417 VGND VGND VPWR VPWR sky130_fd_sc_hd__decap_3
XFILLER_77_277 VGND VGND VPWR VPWR sky130_fd_sc_hd__decap_3
XTAP_TAPCELL_ROW_88_1307 VGND VPWR sky130_fd_sc_hd__tapvpwrvgnd_1
XFILLER_105_90 VGND VGND VPWR VPWR sky130_fd_sc_hd__decap_3
XFILLER_18_333 VGND VGND VPWR VPWR sky130_fd_sc_hd__decap_3
XFILLER_58_480 VGND VGND VPWR VPWR sky130_fd_sc_hd__decap_3
XFILLER_58_491 VGND VGND VPWR VPWR sky130_fd_sc_hd__decap_3
XFILLER_65_50 VGND VGND VPWR VPWR sky130_fd_sc_hd__decap_3
XFILLER_45_152 VGND VGND VPWR VPWR sky130_fd_sc_hd__decap_3
XFILLER_73_472 VGND VGND VPWR VPWR sky130_fd_sc_hd__decap_3
XFILLER_80_409 VGND VGND VPWR VPWR sky130_fd_sc_hd__decap_3
XFILLER_45_185 VGND VGND VPWR VPWR sky130_fd_sc_hd__decap_3
XFILLER_60_100 VGND VGND VPWR VPWR sky130_fd_sc_hd__decap_3
XFILLER_60_122 VGND VGND VPWR VPWR sky130_fd_sc_hd__decap_3
XFILLER_61_623 VGND VGND VPWR VPWR sky130_fd_sc_hd__fill_1
XFILLER_33_358 VGND VGND VPWR VPWR sky130_fd_sc_hd__decap_3
XFILLER_60_133 VGND VGND VPWR VPWR sky130_fd_sc_hd__decap_3
XFILLER_14_583 VGND VGND VPWR VPWR sky130_fd_sc_hd__decap_3
XFILLER_81_60 VGND VGND VPWR VPWR sky130_fd_sc_hd__decap_3
XTAP_TAPCELL_ROW_99_1436 VGND VPWR sky130_fd_sc_hd__tapvpwrvgnd_1
X_3640_ _3635_/X _3637_/X _3639_/X VGND VGND VPWR VPWR _3640_/X sky130_fd_sc_hd__o21ba_2
X_3571_ _3326_/A _3424_/S _5648_/B _3569_/X _3570_/X VGND VGND VPWR VPWR _3607_/B
+ sky130_fd_sc_hd__o32a_2
XFILLER_53_3 VGND VGND VPWR VPWR sky130_fd_sc_hd__decap_3
X_6290_ _6388_/A VGND VGND VPWR VPWR _6290_/Y sky130_fd_sc_hd__inv_2
X_5310_ _5310_/A0 _4836_/X _5325_/S VGND VGND VPWR VPWR _7175_/D sky130_fd_sc_hd__mux2_2
XFILLER_114_135 VGND VGND VPWR VPWR sky130_fd_sc_hd__fill_1
XFILLER_5_281 VGND VGND VPWR VPWR sky130_fd_sc_hd__decap_3
XFILLER_114_168 VGND VGND VPWR VPWR sky130_fd_sc_hd__fill_1
X_5241_ _5241_/A0 _4806_/X _5245_/S VGND VGND VPWR VPWR _7209_/D sky130_fd_sc_hd__mux2_2
XFILLER_68_200 VGND VGND VPWR VPWR sky130_fd_sc_hd__decap_3
XFILLER_68_233 VGND VGND VPWR VPWR sky130_fd_sc_hd__fill_2
X_4123_ _4119_/X _4122_/X _4327_/A VGND VGND VPWR VPWR _4124_/B sky130_fd_sc_hd__o21a_2
XFILLER_110_374 VGND VGND VPWR VPWR sky130_fd_sc_hd__fill_1
XFILLER_28_119 VGND VGND VPWR VPWR sky130_fd_sc_hd__decap_3
XFILLER_56_417 VGND VGND VPWR VPWR sky130_fd_sc_hd__decap_3
XFILLER_68_288 VGND VGND VPWR VPWR sky130_fd_sc_hd__decap_3
XFILLER_83_214 VGND VGND VPWR VPWR sky130_fd_sc_hd__decap_3
XFILLER_96_575 VGND VGND VPWR VPWR sky130_fd_sc_hd__decap_3
X_4054_ _4054_/A _4456_/A VGND VGND VPWR VPWR _4658_/A sky130_fd_sc_hd__nand2_2
XFILLER_83_225 VGND VGND VPWR VPWR sky130_fd_sc_hd__decap_3
XFILLER_83_258 VGND VGND VPWR VPWR sky130_fd_sc_hd__decap_3
XFILLER_36_152 VGND VGND VPWR VPWR sky130_fd_sc_hd__decap_3
XTAP_TAPCELL_ROW_108_1543 VGND VPWR sky130_fd_sc_hd__tapvpwrvgnd_1
XFILLER_24_325 VGND VGND VPWR VPWR sky130_fd_sc_hd__decap_3
XFILLER_36_185 VGND VGND VPWR VPWR sky130_fd_sc_hd__decap_3
XFILLER_51_111 VGND VGND VPWR VPWR sky130_fd_sc_hd__fill_1
XFILLER_64_483 VGND VGND VPWR VPWR sky130_fd_sc_hd__fill_2
XFILLER_64_494 VGND VGND VPWR VPWR sky130_fd_sc_hd__decap_3
XFILLER_101_26 VGND VGND VPWR VPWR sky130_fd_sc_hd__decap_3
XFILLER_24_358 VGND VGND VPWR VPWR sky130_fd_sc_hd__decap_3
XFILLER_51_166 VGND VGND VPWR VPWR sky130_fd_sc_hd__fill_2
XFILLER_51_188 VGND VGND VPWR VPWR sky130_fd_sc_hd__decap_3
X_4956_ _4948_/Y _4951_/Y _4954_/X _4955_/X VGND VGND VPWR VPWR _5662_/C sky130_fd_sc_hd__a211o_2
XTAP_TAPCELL_ROW_22_515 VGND VPWR sky130_fd_sc_hd__tapvpwrvgnd_1
XFILLER_32_380 VGND VGND VPWR VPWR sky130_fd_sc_hd__decap_3
X_4887_ _4886_/A _4890_/B _4814_/A VGND VGND VPWR VPWR _4887_/Y sky130_fd_sc_hd__a21oi_2
X_3907_ _6781_/Q _3926_/B1 _3925_/B1 _6869_/Q _3906_/X VGND VGND VPWR VPWR _3907_/X
+ sky130_fd_sc_hd__a221o_2
XTAP_TAPCELL_ROW_50_857 VGND VPWR sky130_fd_sc_hd__tapvpwrvgnd_1
XTAP_TAPCELL_ROW_50_846 VGND VPWR sky130_fd_sc_hd__tapvpwrvgnd_1
X_6626_ _6664_/A VGND VGND VPWR VPWR _6626_/Y sky130_fd_sc_hd__inv_2
X_3838_ _6773_/Q _3852_/A2 _3853_/A2 _6761_/Q _3837_/X VGND VGND VPWR VPWR _3838_/X
+ sky130_fd_sc_hd__a221o_2
X_6557_ _6647_/A VGND VGND VPWR VPWR _6557_/Y sky130_fd_sc_hd__inv_2
XFILLER_106_625 VGND VGND VPWR VPWR sky130_fd_sc_hd__fill_1
XFILLER_3_207 VGND VGND VPWR VPWR sky130_fd_sc_hd__decap_3
X_3769_ _3746_/C _3767_/X _3768_/X _3818_/A2 VGND VGND VPWR VPWR _4944_/B sky130_fd_sc_hd__o31a_2
XFILLER_105_113 VGND VGND VPWR VPWR sky130_fd_sc_hd__decap_3
X_6488_ _6675_/A VGND VGND VPWR VPWR _6488_/Y sky130_fd_sc_hd__inv_2
XFILLER_106_669 VGND VGND VPWR VPWR sky130_fd_sc_hd__fill_2
XTAP_TAPCELL_ROW_72_1119 VGND VPWR sky130_fd_sc_hd__tapvpwrvgnd_1
XFILLER_59_200 VGND VGND VPWR VPWR sky130_fd_sc_hd__decap_3
XFILLER_86_38 VGND VGND VPWR VPWR sky130_fd_sc_hd__decap_3
XFILLER_87_520 VGND VGND VPWR VPWR sky130_fd_sc_hd__decap_3
XFILLER_87_564 VGND VGND VPWR VPWR sky130_fd_sc_hd__decap_3
X_7109_ _7361_/CLK _7109_/D _6389_/Y VGND VGND VPWR VPWR _7109_/Q sky130_fd_sc_hd__dfrtp_2
XFILLER_99_391 VGND VGND VPWR VPWR sky130_fd_sc_hd__fill_1
XFILLER_101_363 VGND VGND VPWR VPWR sky130_fd_sc_hd__decap_3
XFILLER_19_43 VGND VGND VPWR VPWR sky130_fd_sc_hd__decap_3
XFILLER_47_417 VGND VGND VPWR VPWR sky130_fd_sc_hd__decap_3
XFILLER_74_203 VGND VGND VPWR VPWR sky130_fd_sc_hd__fill_1
XFILLER_101_396 VGND VGND VPWR VPWR sky130_fd_sc_hd__decap_3
XFILLER_59_299 VGND VGND VPWR VPWR sky130_fd_sc_hd__decap_3
XFILLER_74_236 VGND VGND VPWR VPWR sky130_fd_sc_hd__decap_3
XTAP_TAPCELL_ROW_58_946 VGND VPWR sky130_fd_sc_hd__tapvpwrvgnd_1
XFILLER_27_152 VGND VGND VPWR VPWR sky130_fd_sc_hd__decap_3
XFILLER_55_461 VGND VGND VPWR VPWR sky130_fd_sc_hd__decap_3
XFILLER_62_409 VGND VGND VPWR VPWR sky130_fd_sc_hd__decap_3
XTAP_TAPCELL_ROW_2_273 VGND VPWR sky130_fd_sc_hd__tapvpwrvgnd_1
XFILLER_15_325 VGND VGND VPWR VPWR sky130_fd_sc_hd__decap_3
XFILLER_35_42 VGND VGND VPWR VPWR sky130_fd_sc_hd__fill_1
XFILLER_42_100 VGND VGND VPWR VPWR sky130_fd_sc_hd__decap_3
XFILLER_15_358 VGND VGND VPWR VPWR sky130_fd_sc_hd__decap_3
XFILLER_27_196 VGND VGND VPWR VPWR sky130_fd_sc_hd__decap_3
XFILLER_42_144 VGND VGND VPWR VPWR sky130_fd_sc_hd__fill_2
XFILLER_70_453 VGND VGND VPWR VPWR sky130_fd_sc_hd__decap_3
XTAP_TAPCELL_ROW_83_1248 VGND VPWR sky130_fd_sc_hd__tapvpwrvgnd_1
XFILLER_70_486 VGND VGND VPWR VPWR sky130_fd_sc_hd__decap_3
XFILLER_23_391 VGND VGND VPWR VPWR sky130_fd_sc_hd__fill_1
XFILLER_109_452 VGND VGND VPWR VPWR sky130_fd_sc_hd__decap_3
XTAP_TAPCELL_ROW_94_1377 VGND VPWR sky130_fd_sc_hd__tapvpwrvgnd_1
XFILLER_111_116 VGND VGND VPWR VPWR sky130_fd_sc_hd__decap_3
XFILLER_111_138 VGND VGND VPWR VPWR sky130_fd_sc_hd__decap_3
XFILLER_78_531 VGND VGND VPWR VPWR sky130_fd_sc_hd__fill_1
XFILLER_78_586 VGND VGND VPWR VPWR sky130_fd_sc_hd__fill_2
XFILLER_18_6 VGND VGND VPWR VPWR sky130_fd_sc_hd__decap_3
XFILLER_19_620 VGND VGND VPWR VPWR sky130_fd_sc_hd__fill_1
XFILLER_65_225 VGND VGND VPWR VPWR sky130_fd_sc_hd__decap_3
XFILLER_76_71 VGND VGND VPWR VPWR sky130_fd_sc_hd__decap_3
XFILLER_18_141 VGND VGND VPWR VPWR sky130_fd_sc_hd__decap_3
XFILLER_65_269 VGND VGND VPWR VPWR sky130_fd_sc_hd__decap_3
XFILLER_93_578 VGND VGND VPWR VPWR sky130_fd_sc_hd__fill_2
XFILLER_46_483 VGND VGND VPWR VPWR sky130_fd_sc_hd__fill_2
XFILLER_80_228 VGND VGND VPWR VPWR sky130_fd_sc_hd__decap_3
XFILLER_33_144 VGND VGND VPWR VPWR sky130_fd_sc_hd__decap_3
XFILLER_34_645 VGND VGND VPWR VPWR sky130_fd_sc_hd__fill_2
XFILLER_92_70 VGND VGND VPWR VPWR sky130_fd_sc_hd__decap_3
X_4810_ _4813_/A _4810_/B _4829_/B VGND VGND VPWR VPWR _4810_/X sky130_fd_sc_hd__or3_2
XFILLER_61_464 VGND VGND VPWR VPWR sky130_fd_sc_hd__decap_3
XFILLER_14_391 VGND VGND VPWR VPWR sky130_fd_sc_hd__fill_2
XFILLER_33_199 VGND VGND VPWR VPWR sky130_fd_sc_hd__decap_3
X_4741_ _4761_/B _4761_/C _4762_/B VGND VGND VPWR VPWR _4741_/X sky130_fd_sc_hd__a21o_2
XTAP_TAPCELL_ROW_103_1484 VGND VPWR sky130_fd_sc_hd__tapvpwrvgnd_1
X_4672_ _6991_/Q _5605_/B VGND VGND VPWR VPWR _4673_/B sky130_fd_sc_hd__nor2_2
X_6411_ _6535_/A VGND VGND VPWR VPWR _6411_/Y sky130_fd_sc_hd__inv_2
X_7391_ _7394_/CLK _7391_/D _6671_/Y VGND VGND VPWR VPWR _7391_/Q sky130_fd_sc_hd__dfrtp_2
X_6342_ _6347_/A VGND VGND VPWR VPWR _6342_/Y sky130_fd_sc_hd__inv_2
X_3554_ _7317_/Q _3994_/S _4338_/B1 _7349_/Q VGND VGND VPWR VPWR _3556_/B sky130_fd_sc_hd__a22o_2
XFILLER_103_617 VGND VGND VPWR VPWR sky130_fd_sc_hd__decap_3
XFILLER_115_455 VGND VGND VPWR VPWR sky130_fd_sc_hd__decap_3
XFILLER_88_306 VGND VGND VPWR VPWR sky130_fd_sc_hd__fill_2
X_6273_ _6523_/A VGND VGND VPWR VPWR _6273_/Y sky130_fd_sc_hd__inv_2
X_3485_ _3502_/A _3502_/B _3485_/C VGND VGND VPWR VPWR _5144_/A sky130_fd_sc_hd__or3_4
XFILLER_103_639 VGND VGND VPWR VPWR sky130_fd_sc_hd__fill_2
XFILLER_69_520 VGND VGND VPWR VPWR sky130_fd_sc_hd__decap_3
XFILLER_69_553 VGND VGND VPWR VPWR sky130_fd_sc_hd__decap_3
XFILLER_111_683 VGND VGND VPWR VPWR sky130_fd_sc_hd__decap_3
XFILLER_29_428 VGND VGND VPWR VPWR sky130_fd_sc_hd__decap_3
XFILLER_56_203 VGND VGND VPWR VPWR sky130_fd_sc_hd__decap_3
XFILLER_69_586 VGND VGND VPWR VPWR sky130_fd_sc_hd__fill_2
XFILLER_84_501 VGND VGND VPWR VPWR sky130_fd_sc_hd__decap_3
X_5155_ _4467_/B _3923_/X _5151_/X _5154_/Y VGND VGND VPWR VPWR _5155_/X sky130_fd_sc_hd__a31o_2
XFILLER_110_182 VGND VGND VPWR VPWR sky130_fd_sc_hd__decap_3
XFILLER_56_236 VGND VGND VPWR VPWR sky130_fd_sc_hd__fill_1
XFILLER_84_545 VGND VGND VPWR VPWR sky130_fd_sc_hd__decap_3
XFILLER_96_383 VGND VGND VPWR VPWR sky130_fd_sc_hd__decap_3
X_5086_ _5086_/A _5101_/B _5100_/B VGND VGND VPWR VPWR _5086_/X sky130_fd_sc_hd__and3_2
X_4106_ _7141_/Q _4434_/B1 _4103_/X _4105_/X VGND VGND VPWR VPWR _4106_/X sky130_fd_sc_hd__a211o_2
XFILLER_37_461 VGND VGND VPWR VPWR sky130_fd_sc_hd__decap_3
XFILLER_44_409 VGND VGND VPWR VPWR sky130_fd_sc_hd__decap_3
XFILLER_84_567 VGND VGND VPWR VPWR sky130_fd_sc_hd__decap_3
XFILLER_84_589 VGND VGND VPWR VPWR sky130_fd_sc_hd__decap_3
X_4037_ _4394_/A _4394_/B _4036_/X VGND VGND VPWR VPWR _4458_/A sky130_fd_sc_hd__or3b_2
XTAP_TAPCELL_ROW_55_916 VGND VPWR sky130_fd_sc_hd__tapvpwrvgnd_1
XFILLER_64_280 VGND VGND VPWR VPWR sky130_fd_sc_hd__fill_1
XFILLER_71_228 VGND VGND VPWR VPWR sky130_fd_sc_hd__decap_3
XTAP_TAPCELL_ROW_69_1081 VGND VPWR sky130_fd_sc_hd__tapvpwrvgnd_1
XFILLER_24_144 VGND VGND VPWR VPWR sky130_fd_sc_hd__fill_1
XFILLER_52_442 VGND VGND VPWR VPWR sky130_fd_sc_hd__decap_3
XFILLER_72_18 VGND VGND VPWR VPWR sky130_fd_sc_hd__decap_3
XFILLER_72_29 VGND VGND VPWR VPWR sky130_fd_sc_hd__decap_3
XFILLER_24_177 VGND VGND VPWR VPWR sky130_fd_sc_hd__decap_3
XTAP_TAPCELL_ROW_35_673 VGND VPWR sky130_fd_sc_hd__tapvpwrvgnd_1
XFILLER_12_339 VGND VGND VPWR VPWR sky130_fd_sc_hd__decap_3
X_4939_ _4764_/B _4379_/B _4938_/Y _4937_/A _4852_/A VGND VGND VPWR VPWR _4939_/X
+ sky130_fd_sc_hd__o32a_2
XFILLER_20_383 VGND VGND VPWR VPWR sky130_fd_sc_hd__decap_3
X_6609_ _6643_/A VGND VGND VPWR VPWR _6609_/Y sky130_fd_sc_hd__inv_2
XFILLER_106_433 VGND VGND VPWR VPWR sky130_fd_sc_hd__decap_3
XFILLER_21_77 VGND VGND VPWR VPWR sky130_fd_sc_hd__decap_3
XFILLER_4_527 VGND VGND VPWR VPWR sky130_fd_sc_hd__decap_3
XFILLER_79_306 VGND VGND VPWR VPWR sky130_fd_sc_hd__decap_3
XFILLER_97_15 VGND VGND VPWR VPWR sky130_fd_sc_hd__decap_3
XFILLER_106_477 VGND VGND VPWR VPWR sky130_fd_sc_hd__decap_3
XTAP_TAPCELL_ROW_7_332 VGND VPWR sky130_fd_sc_hd__tapvpwrvgnd_1
XFILLER_102_683 VGND VGND VPWR VPWR sky130_fd_sc_hd__fill_1
XFILLER_87_361 VGND VGND VPWR VPWR sky130_fd_sc_hd__decap_3
XFILLER_94_309 VGND VGND VPWR VPWR sky130_fd_sc_hd__decap_3
XFILLER_101_160 VGND VGND VPWR VPWR sky130_fd_sc_hd__fill_1
XFILLER_47_214 VGND VGND VPWR VPWR sky130_fd_sc_hd__fill_1
XFILLER_47_225 VGND VGND VPWR VPWR sky130_fd_sc_hd__decap_3
XFILLER_75_534 VGND VGND VPWR VPWR sky130_fd_sc_hd__decap_3
XFILLER_46_52 VGND VGND VPWR VPWR sky130_fd_sc_hd__decap_3
XFILLER_47_258 VGND VGND VPWR VPWR sky130_fd_sc_hd__decap_3
XFILLER_75_567 VGND VGND VPWR VPWR sky130_fd_sc_hd__decap_3
XFILLER_90_504 VGND VGND VPWR VPWR sky130_fd_sc_hd__fill_1
XFILLER_15_100 VGND VGND VPWR VPWR sky130_fd_sc_hd__decap_3
XFILLER_28_461 VGND VGND VPWR VPWR sky130_fd_sc_hd__decap_3
XFILLER_28_483 VGND VGND VPWR VPWR sky130_fd_sc_hd__fill_1
XFILLER_46_85 VGND VGND VPWR VPWR sky130_fd_sc_hd__decap_3
XFILLER_62_228 VGND VGND VPWR VPWR sky130_fd_sc_hd__decap_3
XFILLER_90_526 VGND VGND VPWR VPWR sky130_fd_sc_hd__decap_3
XFILLER_15_122 VGND VGND VPWR VPWR sky130_fd_sc_hd__fill_2
XFILLER_43_431 VGND VGND VPWR VPWR sky130_fd_sc_hd__decap_3
XFILLER_102_80 VGND VGND VPWR VPWR sky130_fd_sc_hd__decap_3
XFILLER_102_91 VGND VGND VPWR VPWR sky130_fd_sc_hd__decap_3
XFILLER_70_250 VGND VGND VPWR VPWR sky130_fd_sc_hd__fill_2
XFILLER_15_199 VGND VGND VPWR VPWR sky130_fd_sc_hd__decap_3
XFILLER_30_114 VGND VGND VPWR VPWR sky130_fd_sc_hd__decap_3
XFILLER_62_73 VGND VGND VPWR VPWR sky130_fd_sc_hd__decap_3
XFILLER_70_294 VGND VGND VPWR VPWR sky130_fd_sc_hd__decap_3
XFILLER_30_147 VGND VGND VPWR VPWR sky130_fd_sc_hd__decap_3
XFILLER_87_9 VGND VGND VPWR VPWR sky130_fd_sc_hd__decap_3
XFILLER_11_361 VGND VGND VPWR VPWR sky130_fd_sc_hd__decap_3
XFILLER_7_35 VGND VGND VPWR VPWR sky130_fd_sc_hd__decap_3
XTAP_TAPCELL_ROW_96_1406 VGND VPWR sky130_fd_sc_hd__tapvpwrvgnd_1
XFILLER_7_343 VGND VGND VPWR VPWR sky130_fd_sc_hd__decap_3
XFILLER_7_57 VGND VGND VPWR VPWR sky130_fd_sc_hd__decap_3
XFILLER_109_293 VGND VGND VPWR VPWR sky130_fd_sc_hd__decap_3
XFILLER_7_376 VGND VGND VPWR VPWR sky130_fd_sc_hd__decap_3
XFILLER_97_103 VGND VGND VPWR VPWR sky130_fd_sc_hd__decap_3
XFILLER_97_125 VGND VGND VPWR VPWR sky130_fd_sc_hd__decap_3
XFILLER_98_648 VGND VGND VPWR VPWR sky130_fd_sc_hd__decap_3
XFILLER_98_626 VGND VGND VPWR VPWR sky130_fd_sc_hd__decap_3
XFILLER_112_436 VGND VGND VPWR VPWR sky130_fd_sc_hd__fill_1
XFILLER_97_147 VGND VGND VPWR VPWR sky130_fd_sc_hd__fill_2
XFILLER_66_501 VGND VGND VPWR VPWR sky130_fd_sc_hd__decap_3
XFILLER_97_169 VGND VGND VPWR VPWR sky130_fd_sc_hd__decap_3
XFILLER_16_3 VGND VGND VPWR VPWR sky130_fd_sc_hd__decap_3
XFILLER_38_214 VGND VGND VPWR VPWR sky130_fd_sc_hd__fill_1
XFILLER_38_236 VGND VGND VPWR VPWR sky130_fd_sc_hd__decap_3
XFILLER_66_545 VGND VGND VPWR VPWR sky130_fd_sc_hd__decap_3
XFILLER_78_383 VGND VGND VPWR VPWR sky130_fd_sc_hd__decap_3
XFILLER_93_331 VGND VGND VPWR VPWR sky130_fd_sc_hd__decap_3
XFILLER_93_364 VGND VGND VPWR VPWR sky130_fd_sc_hd__decap_3
X_6960_ _6966_/CLK _6960_/D VGND VGND VPWR VPWR _6960_/Q sky130_fd_sc_hd__dfxtp_2
XFILLER_53_228 VGND VGND VPWR VPWR sky130_fd_sc_hd__decap_3
XFILLER_81_526 VGND VGND VPWR VPWR sky130_fd_sc_hd__decap_3
XTAP_TAPCELL_ROW_105_1513 VGND VPWR sky130_fd_sc_hd__tapvpwrvgnd_1
XFILLER_81_559 VGND VGND VPWR VPWR sky130_fd_sc_hd__fill_1
X_6891_ _7404_/CLK _6891_/D VGND VGND VPWR VPWR _6891_/Q sky130_fd_sc_hd__dfxtp_2
XFILLER_34_475 VGND VGND VPWR VPWR sky130_fd_sc_hd__fill_1
XFILLER_61_250 VGND VGND VPWR VPWR sky130_fd_sc_hd__decap_3
XFILLER_21_136 VGND VGND VPWR VPWR sky130_fd_sc_hd__decap_3
XTAP_TAPCELL_ROW_32_632 VGND VPWR sky130_fd_sc_hd__tapvpwrvgnd_1
XFILLER_21_169 VGND VGND VPWR VPWR sky130_fd_sc_hd__decap_3
X_4724_ _4720_/A _4655_/X _4658_/B VGND VGND VPWR VPWR _4724_/X sky130_fd_sc_hd__o21a_2
XTAP_TAPCELL_ROW_60_974 VGND VPWR sky130_fd_sc_hd__tapvpwrvgnd_1
XFILLER_107_208 VGND VGND VPWR VPWR sky130_fd_sc_hd__decap_3
X_4655_ _4610_/A _4765_/B _4611_/Y _4762_/A _4744_/B VGND VGND VPWR VPWR _4655_/X
+ sky130_fd_sc_hd__a221o_2
X_7374_ _7403_/CLK _7374_/D _6654_/Y VGND VGND VPWR VPWR _7374_/Q sky130_fd_sc_hd__dfrtp_2
Xhold800 _6953_/Q VGND VGND VPWR VPWR _6953_/D sky130_fd_sc_hd__dlygate4sd3_1
Xhold811 _6926_/Q VGND VGND VPWR VPWR _6926_/D sky130_fd_sc_hd__dlygate4sd3_1
X_3606_ _4614_/B _3603_/B _4811_/C VGND VGND VPWR VPWR _3606_/X sky130_fd_sc_hd__o21a_2
XTAP_TAPCELL_ROW_116_1642 VGND VPWR sky130_fd_sc_hd__tapvpwrvgnd_1
Xhold822 _6879_/Q VGND VGND VPWR VPWR _6879_/D sky130_fd_sc_hd__dlygate4sd3_1
Xhold833 _6971_/Q VGND VGND VPWR VPWR _6971_/D sky130_fd_sc_hd__dlygate4sd3_1
Xhold844 _6894_/Q VGND VGND VPWR VPWR _6894_/D sky130_fd_sc_hd__dlygate4sd3_1
Xhold855 _7103_/Q VGND VGND VPWR VPWR _7103_/D sky130_fd_sc_hd__dlygate4sd3_1
Xmax_cap563 _4186_/Y VGND VGND VPWR VPWR _4950_/A sky130_fd_sc_hd__buf_2
X_6325_ _6674_/A VGND VGND VPWR VPWR _6325_/Y sky130_fd_sc_hd__inv_2
X_3537_ _3427_/B _3618_/C _5057_/A _3527_/A _3536_/Y VGND VGND VPWR VPWR _3537_/X
+ sky130_fd_sc_hd__o221a_2
XTAP_TAPCELL_ROW_116_1653 VGND VPWR sky130_fd_sc_hd__tapvpwrvgnd_1
XFILLER_115_285 VGND VGND VPWR VPWR sky130_fd_sc_hd__decap_3
XFILLER_88_114 VGND VGND VPWR VPWR sky130_fd_sc_hd__decap_3
XFILLER_89_615 VGND VGND VPWR VPWR sky130_fd_sc_hd__fill_1
XFILLER_89_626 VGND VGND VPWR VPWR sky130_fd_sc_hd__decap_3
Xhold866 _7098_/Q VGND VGND VPWR VPWR _7098_/D sky130_fd_sc_hd__dlygate4sd3_1
Xhold877 _7095_/Q VGND VGND VPWR VPWR _7095_/D sky130_fd_sc_hd__dlygate4sd3_1
Xhold888 _7062_/Q VGND VGND VPWR VPWR _7062_/D sky130_fd_sc_hd__dlygate4sd3_1
Xmax_cap574 _3383_/Y VGND VGND VPWR VPWR _4505_/S sky130_fd_sc_hd__buf_2
XFILLER_103_458 VGND VGND VPWR VPWR sky130_fd_sc_hd__fill_2
XFILLER_107_69 VGND VGND VPWR VPWR sky130_fd_sc_hd__decap_3
XFILLER_67_29 VGND VGND VPWR VPWR sky130_fd_sc_hd__decap_3
XFILLER_88_147 VGND VGND VPWR VPWR sky130_fd_sc_hd__decap_3
XFILLER_89_659 VGND VGND VPWR VPWR sky130_fd_sc_hd__decap_3
Xhold899 _7088_/Q VGND VGND VPWR VPWR _7088_/D sky130_fd_sc_hd__dlygate4sd3_1
X_3468_ _7281_/Q _5159_/S _4351_/A2 _7089_/Q _3467_/X VGND VGND VPWR VPWR _3468_/X
+ sky130_fd_sc_hd__a221o_2
XFILLER_57_501 VGND VGND VPWR VPWR sky130_fd_sc_hd__decap_3
XFILLER_69_361 VGND VGND VPWR VPWR sky130_fd_sc_hd__fill_1
XFILLER_69_372 VGND VGND VPWR VPWR sky130_fd_sc_hd__decap_3
X_5207_ _5207_/A _5217_/B VGND VGND VPWR VPWR _7225_/D sky130_fd_sc_hd__and2_2
X_3399_ _3399_/A _3399_/B VGND VGND VPWR VPWR _3449_/B sky130_fd_sc_hd__nor2_4
XTAP_TAPCELL_ROW_4_302 VGND VPWR sky130_fd_sc_hd__tapvpwrvgnd_1
XFILLER_111_480 VGND VGND VPWR VPWR sky130_fd_sc_hd__decap_3
XFILLER_29_214 VGND VGND VPWR VPWR sky130_fd_sc_hd__decap_3
XFILLER_29_225 VGND VGND VPWR VPWR sky130_fd_sc_hd__decap_3
XFILLER_57_534 VGND VGND VPWR VPWR sky130_fd_sc_hd__fill_2
XFILLER_84_320 VGND VGND VPWR VPWR sky130_fd_sc_hd__decap_3
XFILLER_96_180 VGND VGND VPWR VPWR sky130_fd_sc_hd__decap_3
X_5138_ _3665_/B _3914_/X _5138_/S VGND VGND VPWR VPWR _5138_/X sky130_fd_sc_hd__mux2_2
XFILLER_57_556 VGND VGND VPWR VPWR sky130_fd_sc_hd__decap_3
XFILLER_57_567 VGND VGND VPWR VPWR sky130_fd_sc_hd__decap_3
XFILLER_84_353 VGND VGND VPWR VPWR sky130_fd_sc_hd__fill_1
XFILLER_44_206 VGND VGND VPWR VPWR sky130_fd_sc_hd__decap_3
XFILLER_72_526 VGND VGND VPWR VPWR sky130_fd_sc_hd__decap_3
XFILLER_84_386 VGND VGND VPWR VPWR sky130_fd_sc_hd__decap_3
X_5069_ _6987_/Q _5069_/B VGND VGND VPWR VPWR _5069_/X sky130_fd_sc_hd__or2_2
XFILLER_16_66 VGND VGND VPWR VPWR sky130_fd_sc_hd__decap_3
XTAP_TAPCELL_ROW_80_1207 VGND VPWR sky130_fd_sc_hd__tapvpwrvgnd_1
XFILLER_12_125 VGND VGND VPWR VPWR sky130_fd_sc_hd__decap_3
XFILLER_16_99 VGND VGND VPWR VPWR sky130_fd_sc_hd__decap_3
XFILLER_52_283 VGND VGND VPWR VPWR sky130_fd_sc_hd__decap_3
XFILLER_80_581 VGND VGND VPWR VPWR sky130_fd_sc_hd__decap_3
XFILLER_80_592 VGND VGND VPWR VPWR sky130_fd_sc_hd__decap_3
XFILLER_12_147 VGND VGND VPWR VPWR sky130_fd_sc_hd__decap_3
XFILLER_12_169 VGND VGND VPWR VPWR sky130_fd_sc_hd__decap_3
XFILLER_8_118 VGND VGND VPWR VPWR sky130_fd_sc_hd__decap_3
XFILLER_32_32 VGND VGND VPWR VPWR sky130_fd_sc_hd__fill_1
XFILLER_32_54 VGND VGND VPWR VPWR sky130_fd_sc_hd__decap_3
XFILLER_40_489 VGND VGND VPWR VPWR sky130_fd_sc_hd__decap_3
XFILLER_20_180 VGND VGND VPWR VPWR sky130_fd_sc_hd__fill_2
XFILLER_20_191 VGND VGND VPWR VPWR sky130_fd_sc_hd__decap_3
XFILLER_4_324 VGND VGND VPWR VPWR sky130_fd_sc_hd__decap_3
XPHY_EDGE_ROW_112_Left_229 VGND VGND VPWR VPWR sky130_fd_sc_hd__decap_3
XFILLER_4_357 VGND VGND VPWR VPWR sky130_fd_sc_hd__decap_3
XFILLER_4_368 VGND VGND VPWR VPWR sky130_fd_sc_hd__decap_3
XTAP_TAPCELL_ROW_91_1347 VGND VPWR sky130_fd_sc_hd__tapvpwrvgnd_1
XFILLER_106_285 VGND VGND VPWR VPWR sky130_fd_sc_hd__decap_3
XFILLER_0_541 VGND VGND VPWR VPWR sky130_fd_sc_hd__fill_2
XFILLER_79_169 VGND VGND VPWR VPWR sky130_fd_sc_hd__decap_3
XFILLER_102_480 VGND VGND VPWR VPWR sky130_fd_sc_hd__decap_3
XFILLER_94_139 VGND VGND VPWR VPWR sky130_fd_sc_hd__fill_1
XFILLER_57_84 VGND VGND VPWR VPWR sky130_fd_sc_hd__fill_2
XFILLER_75_364 VGND VGND VPWR VPWR sky130_fd_sc_hd__decap_3
XFILLER_87_191 VGND VGND VPWR VPWR sky130_fd_sc_hd__decap_3
XFILLER_63_537 VGND VGND VPWR VPWR sky130_fd_sc_hd__decap_3
XFILLER_75_386 VGND VGND VPWR VPWR sky130_fd_sc_hd__decap_3
XFILLER_90_301 VGND VGND VPWR VPWR sky130_fd_sc_hd__decap_3
XFILLER_90_312 VGND VGND VPWR VPWR sky130_fd_sc_hd__decap_3
XFILLER_113_90 VGND VGND VPWR VPWR sky130_fd_sc_hd__decap_3
XFILLER_16_442 VGND VGND VPWR VPWR sky130_fd_sc_hd__decap_3
XFILLER_28_280 VGND VGND VPWR VPWR sky130_fd_sc_hd__fill_1
XFILLER_35_239 VGND VGND VPWR VPWR sky130_fd_sc_hd__decap_3
XFILLER_90_345 VGND VGND VPWR VPWR sky130_fd_sc_hd__decap_3
XFILLER_16_464 VGND VGND VPWR VPWR sky130_fd_sc_hd__decap_3
XFILLER_50_209 VGND VGND VPWR VPWR sky130_fd_sc_hd__fill_2
XFILLER_71_570 VGND VGND VPWR VPWR sky130_fd_sc_hd__decap_3
XFILLER_73_72 VGND VGND VPWR VPWR sky130_fd_sc_hd__decap_3
XFILLER_16_486 VGND VGND VPWR VPWR sky130_fd_sc_hd__decap_3
XFILLER_31_434 VGND VGND VPWR VPWR sky130_fd_sc_hd__decap_3
XFILLER_43_272 VGND VGND VPWR VPWR sky130_fd_sc_hd__decap_3
XFILLER_31_478 VGND VGND VPWR VPWR sky130_fd_sc_hd__fill_2
XTAP_TAPCELL_ROW_100_1454 VGND VPWR sky130_fd_sc_hd__tapvpwrvgnd_1
XFILLER_7_151 VGND VGND VPWR VPWR sky130_fd_sc_hd__decap_3
XFILLER_7_184 VGND VGND VPWR VPWR sky130_fd_sc_hd__decap_3
X_4440_ _4440_/A _4650_/B VGND VGND VPWR VPWR _4441_/B sky130_fd_sc_hd__nand2_2
XFILLER_112_200 VGND VGND VPWR VPWR sky130_fd_sc_hd__decap_3
X_4371_ _4371_/A _4371_/B VGND VGND VPWR VPWR _4371_/Y sky130_fd_sc_hd__nand2_2
XFILLER_98_412 VGND VGND VPWR VPWR sky130_fd_sc_hd__decap_3
X_7090_ clkload4/A _7090_/D _6370_/Y VGND VGND VPWR VPWR _7090_/Q sky130_fd_sc_hd__dfrtp_2
XFILLER_98_456 VGND VGND VPWR VPWR sky130_fd_sc_hd__fill_1
XFILLER_112_277 VGND VGND VPWR VPWR sky130_fd_sc_hd__decap_3
XFILLER_98_489 VGND VGND VPWR VPWR sky130_fd_sc_hd__decap_3
XFILLER_100_439 VGND VGND VPWR VPWR sky130_fd_sc_hd__decap_3
XFILLER_39_523 VGND VGND VPWR VPWR sky130_fd_sc_hd__fill_1
XFILLER_85_139 VGND VGND VPWR VPWR sky130_fd_sc_hd__decap_3
XTAP_TAPCELL_ROW_111_1583 VGND VPWR sky130_fd_sc_hd__tapvpwrvgnd_1
XFILLER_39_578 VGND VGND VPWR VPWR sky130_fd_sc_hd__fill_2
XFILLER_78_191 VGND VGND VPWR VPWR sky130_fd_sc_hd__decap_3
XFILLER_94_651 VGND VGND VPWR VPWR sky130_fd_sc_hd__decap_3
XFILLER_26_206 VGND VGND VPWR VPWR sky130_fd_sc_hd__decap_3
XFILLER_54_537 VGND VGND VPWR VPWR sky130_fd_sc_hd__fill_2
XFILLER_81_312 VGND VGND VPWR VPWR sky130_fd_sc_hd__decap_3
XFILLER_93_161 VGND VGND VPWR VPWR sky130_fd_sc_hd__decap_3
XFILLER_93_172 VGND VGND VPWR VPWR sky130_fd_sc_hd__decap_3
XFILLER_54_559 VGND VGND VPWR VPWR sky130_fd_sc_hd__decap_3
XFILLER_93_194 VGND VGND VPWR VPWR sky130_fd_sc_hd__fill_2
X_6943_ _6966_/CLK _6943_/D VGND VGND VPWR VPWR _6943_/Q sky130_fd_sc_hd__dfxtp_2
XFILLER_22_401 VGND VGND VPWR VPWR sky130_fd_sc_hd__decap_3
XFILLER_41_209 VGND VGND VPWR VPWR sky130_fd_sc_hd__decap_3
X_6874_ _7351_/CLK _6874_/D VGND VGND VPWR VPWR _6874_/Q sky130_fd_sc_hd__dfxtp_2
XTAP_TAPCELL_ROW_66_1040 VGND VPWR sky130_fd_sc_hd__tapvpwrvgnd_1
XFILLER_34_283 VGND VGND VPWR VPWR sky130_fd_sc_hd__decap_3
XFILLER_62_592 VGND VGND VPWR VPWR sky130_fd_sc_hd__decap_3
XTAP_TAPCELL_ROW_45_790 VGND VPWR sky130_fd_sc_hd__tapvpwrvgnd_1
XFILLER_108_506 VGND VGND VPWR VPWR sky130_fd_sc_hd__fill_2
XFILLER_108_517 VGND VGND VPWR VPWR sky130_fd_sc_hd__decap_3
X_4707_ _6998_/Q _6999_/Q _7000_/Q _4912_/A VGND VGND VPWR VPWR _4825_/B sky130_fd_sc_hd__and4_2
XFILLER_108_539 VGND VGND VPWR VPWR sky130_fd_sc_hd__decap_3
X_4638_ _4950_/A _4950_/B VGND VGND VPWR VPWR _4948_/B sky130_fd_sc_hd__and2_2
Xhold630 _6782_/Q VGND VGND VPWR VPWR _6782_/D sky130_fd_sc_hd__dlygate4sd3_1
XFILLER_116_561 VGND VGND VPWR VPWR sky130_fd_sc_hd__decap_3
XFILLER_78_17 VGND VGND VPWR VPWR sky130_fd_sc_hd__decap_3
XFILLER_89_423 VGND VGND VPWR VPWR sky130_fd_sc_hd__decap_3
X_7357_ _7360_/CLK _7357_/D _6637_/Y VGND VGND VPWR VPWR _7357_/Q sky130_fd_sc_hd__dfrtp_2
Xhold641 _6893_/Q VGND VGND VPWR VPWR _6893_/D sky130_fd_sc_hd__dlygate4sd3_1
Xhold652 _6811_/Q VGND VGND VPWR VPWR _6811_/D sky130_fd_sc_hd__dlygate4sd3_1
Xhold663 _6885_/Q VGND VGND VPWR VPWR _6885_/D sky130_fd_sc_hd__dlygate4sd3_1
X_4569_ _4569_/A _4569_/B VGND VGND VPWR VPWR _7296_/D sky130_fd_sc_hd__and2_2
XTAP_TAPCELL_ROW_77_1180 VGND VPWR sky130_fd_sc_hd__tapvpwrvgnd_1
XFILLER_103_211 VGND VGND VPWR VPWR sky130_fd_sc_hd__decap_3
XFILLER_1_349 VGND VGND VPWR VPWR sky130_fd_sc_hd__fill_1
X_7288_ clkload4/A _7288_/D _6568_/Y VGND VGND VPWR VPWR _7288_/Q sky130_fd_sc_hd__dfrtp_2
Xhold674 _6955_/Q VGND VGND VPWR VPWR _6955_/D sky130_fd_sc_hd__dlygate4sd3_1
Xhold685 _6784_/Q VGND VGND VPWR VPWR _6784_/D sky130_fd_sc_hd__dlygate4sd3_1
Xhold696 _6962_/Q VGND VGND VPWR VPWR _6962_/D sky130_fd_sc_hd__dlygate4sd3_1
X_6308_ _6672_/A VGND VGND VPWR VPWR _6308_/Y sky130_fd_sc_hd__inv_2
XFILLER_49_309 VGND VGND VPWR VPWR sky130_fd_sc_hd__decap_3
XFILLER_77_607 VGND VGND VPWR VPWR sky130_fd_sc_hd__decap_3
XFILLER_89_467 VGND VGND VPWR VPWR sky130_fd_sc_hd__decap_3
XFILLER_103_277 VGND VGND VPWR VPWR sky130_fd_sc_hd__decap_3
XFILLER_103_299 VGND VGND VPWR VPWR sky130_fd_sc_hd__decap_3
XFILLER_57_320 VGND VGND VPWR VPWR sky130_fd_sc_hd__decap_3
XFILLER_76_139 VGND VGND VPWR VPWR sky130_fd_sc_hd__fill_1
XFILLER_85_640 VGND VGND VPWR VPWR sky130_fd_sc_hd__decap_3
XFILLER_94_38 VGND VGND VPWR VPWR sky130_fd_sc_hd__decap_3
XFILLER_17_217 VGND VGND VPWR VPWR sky130_fd_sc_hd__decap_3
XFILLER_17_228 VGND VGND VPWR VPWR sky130_fd_sc_hd__decap_3
XFILLER_57_364 VGND VGND VPWR VPWR sky130_fd_sc_hd__decap_3
XFILLER_72_301 VGND VGND VPWR VPWR sky130_fd_sc_hd__decap_3
XFILLER_84_150 VGND VGND VPWR VPWR sky130_fd_sc_hd__decap_3
XFILLER_84_161 VGND VGND VPWR VPWR sky130_fd_sc_hd__decap_3
XFILLER_85_673 VGND VGND VPWR VPWR sky130_fd_sc_hd__decap_3
XFILLER_27_87 VGND VGND VPWR VPWR sky130_fd_sc_hd__decap_3
XFILLER_72_345 VGND VGND VPWR VPWR sky130_fd_sc_hd__decap_3
XFILLER_84_194 VGND VGND VPWR VPWR sky130_fd_sc_hd__fill_2
XFILLER_60_507 VGND VGND VPWR VPWR sky130_fd_sc_hd__decap_3
XFILLER_72_389 VGND VGND VPWR VPWR sky130_fd_sc_hd__decap_3
XFILLER_13_434 VGND VGND VPWR VPWR sky130_fd_sc_hd__decap_3
XFILLER_25_272 VGND VGND VPWR VPWR sky130_fd_sc_hd__decap_3
XFILLER_40_220 VGND VGND VPWR VPWR sky130_fd_sc_hd__decap_3
XFILLER_43_20 VGND VGND VPWR VPWR sky130_fd_sc_hd__decap_3
XTAP_TAPCELL_ROW_15_429 VGND VPWR sky130_fd_sc_hd__tapvpwrvgnd_1
XFILLER_40_253 VGND VGND VPWR VPWR sky130_fd_sc_hd__decap_3
XFILLER_43_53 VGND VGND VPWR VPWR sky130_fd_sc_hd__decap_3
XFILLER_43_86 VGND VGND VPWR VPWR sky130_fd_sc_hd__decap_3
XFILLER_9_449 VGND VGND VPWR VPWR sky130_fd_sc_hd__decap_3
XFILLER_40_297 VGND VGND VPWR VPWR sky130_fd_sc_hd__decap_3
XFILLER_107_561 VGND VGND VPWR VPWR sky130_fd_sc_hd__decap_3
XFILLER_4_176 VGND VGND VPWR VPWR sky130_fd_sc_hd__decap_3
XFILLER_4_69 VGND VGND VPWR VPWR sky130_fd_sc_hd__fill_2
XFILLER_68_50 VGND VGND VPWR VPWR sky130_fd_sc_hd__decap_3
XFILLER_68_618 VGND VGND VPWR VPWR sky130_fd_sc_hd__decap_3
XFILLER_68_94 VGND VGND VPWR VPWR sky130_fd_sc_hd__decap_3
XFILLER_0_393 VGND VGND VPWR VPWR sky130_fd_sc_hd__decap_3
XFILLER_48_342 VGND VGND VPWR VPWR sky130_fd_sc_hd__decap_3
XFILLER_76_640 VGND VGND VPWR VPWR sky130_fd_sc_hd__fill_1
XFILLER_75_172 VGND VGND VPWR VPWR sky130_fd_sc_hd__decap_3
XFILLER_63_323 VGND VGND VPWR VPWR sky130_fd_sc_hd__decap_3
XFILLER_84_60 VGND VGND VPWR VPWR sky130_fd_sc_hd__fill_1
XFILLER_84_82 VGND VGND VPWR VPWR sky130_fd_sc_hd__fill_2
Xplace312 _4583_/B VGND VGND VPWR VPWR _4595_/B sky130_fd_sc_hd__buf_2
Xplace301 _3651_/Y VGND VGND VPWR VPWR _3889_/A2 sky130_fd_sc_hd__buf_2
XFILLER_23_209 VGND VGND VPWR VPWR sky130_fd_sc_hd__decap_3
XFILLER_63_367 VGND VGND VPWR VPWR sky130_fd_sc_hd__decap_3
Xplace345 _3604_/B VGND VGND VPWR VPWR _5114_/A sky130_fd_sc_hd__buf_2
Xplace334 _3407_/X VGND VGND VPWR VPWR _4351_/B1 sky130_fd_sc_hd__buf_2
Xplace323 _3358_/X VGND VGND VPWR VPWR _4356_/A2 sky130_fd_sc_hd__buf_2
XFILLER_16_283 VGND VGND VPWR VPWR sky130_fd_sc_hd__decap_3
XFILLER_90_175 VGND VGND VPWR VPWR sky130_fd_sc_hd__decap_3
XFILLER_90_197 VGND VGND VPWR VPWR sky130_fd_sc_hd__fill_1
Xplace389 _5194_/B VGND VGND VPWR VPWR _5190_/B sky130_fd_sc_hd__buf_2
Xplace378 _4466_/A VGND VGND VPWR VPWR _4791_/A1 sky130_fd_sc_hd__buf_2
Xplace367 _3577_/B VGND VGND VPWR VPWR _4305_/B sky130_fd_sc_hd__buf_2
Xplace356 _4879_/S VGND VGND VPWR VPWR _4793_/S sky130_fd_sc_hd__buf_2
XFILLER_31_242 VGND VGND VPWR VPWR sky130_fd_sc_hd__decap_3
X_3871_ _6785_/Q _3926_/B1 _3888_/B1 _6873_/Q VGND VGND VPWR VPWR _3871_/X sky130_fd_sc_hd__a22o_2
X_6590_ _6651_/A VGND VGND VPWR VPWR _6590_/Y sky130_fd_sc_hd__inv_2
XTAP_TAPCELL_ROW_42_760 VGND VPWR sky130_fd_sc_hd__tapvpwrvgnd_1
X_7211_ _7330_/CLK _7211_/D _6491_/Y VGND VGND VPWR VPWR _7211_/Q sky130_fd_sc_hd__dfrtp_2
X_4423_ _7080_/Q _4432_/A2 _4432_/B1 _4422_/X VGND VGND VPWR VPWR _4649_/B sky130_fd_sc_hd__o211ai_2
XTAP_TAPCELL_ROW_113_1612 VGND VPWR sky130_fd_sc_hd__tapvpwrvgnd_1
XFILLER_113_520 VGND VGND VPWR VPWR sky130_fd_sc_hd__decap_3
X_7142_ _7365_/CLK _7142_/D _6422_/Y VGND VGND VPWR VPWR _7142_/Q sky130_fd_sc_hd__dfrtp_2
X_4354_ _7038_/Q _4510_/S _4354_/B1 _7385_/Q VGND VGND VPWR VPWR _4355_/B sky130_fd_sc_hd__a22o_2
XFILLER_98_220 VGND VGND VPWR VPWR sky130_fd_sc_hd__fill_2
XFILLER_86_404 VGND VGND VPWR VPWR sky130_fd_sc_hd__decap_3
X_7073_ _7364_/CLK _7073_/D _6353_/Y VGND VGND VPWR VPWR _7073_/Q sky130_fd_sc_hd__dfrtp_2
X_3305_ _4697_/A VGND VGND VPWR VPWR _3340_/B sky130_fd_sc_hd__inv_2
XFILLER_98_253 VGND VGND VPWR VPWR sky130_fd_sc_hd__decap_3
XFILLER_100_225 VGND VGND VPWR VPWR sky130_fd_sc_hd__decap_3
XFILLER_58_139 VGND VGND VPWR VPWR sky130_fd_sc_hd__fill_1
XFILLER_86_448 VGND VGND VPWR VPWR sky130_fd_sc_hd__decap_3
X_4285_ _7035_/Q _4532_/S _4332_/B1 _7382_/Q VGND VGND VPWR VPWR _4286_/B sky130_fd_sc_hd__a22o_2
XFILLER_98_286 VGND VGND VPWR VPWR sky130_fd_sc_hd__fill_2
XFILLER_104_15 VGND VGND VPWR VPWR sky130_fd_sc_hd__decap_3
XFILLER_39_331 VGND VGND VPWR VPWR sky130_fd_sc_hd__decap_3
XFILLER_67_640 VGND VGND VPWR VPWR sky130_fd_sc_hd__decap_3
XFILLER_104_59 VGND VGND VPWR VPWR sky130_fd_sc_hd__decap_3
XFILLER_39_375 VGND VGND VPWR VPWR sky130_fd_sc_hd__decap_3
XFILLER_54_312 VGND VGND VPWR VPWR sky130_fd_sc_hd__fill_2
XFILLER_66_150 VGND VGND VPWR VPWR sky130_fd_sc_hd__decap_3
XFILLER_67_673 VGND VGND VPWR VPWR sky130_fd_sc_hd__fill_1
XFILLER_82_621 VGND VGND VPWR VPWR sky130_fd_sc_hd__decap_3
XFILLER_94_470 VGND VGND VPWR VPWR sky130_fd_sc_hd__decap_3
XFILLER_27_537 VGND VGND VPWR VPWR sky130_fd_sc_hd__decap_3
XFILLER_54_323 VGND VGND VPWR VPWR sky130_fd_sc_hd__decap_3
XFILLER_66_194 VGND VGND VPWR VPWR sky130_fd_sc_hd__fill_2
XFILLER_14_209 VGND VGND VPWR VPWR sky130_fd_sc_hd__fill_2
XFILLER_54_356 VGND VGND VPWR VPWR sky130_fd_sc_hd__decap_3
X_6926_ _6936_/CLK _6926_/D VGND VGND VPWR VPWR _6926_/Q sky130_fd_sc_hd__dfxtp_2
XFILLER_35_581 VGND VGND VPWR VPWR sky130_fd_sc_hd__fill_1
XFILLER_81_175 VGND VGND VPWR VPWR sky130_fd_sc_hd__decap_3
XFILLER_22_242 VGND VGND VPWR VPWR sky130_fd_sc_hd__decap_3
XFILLER_80_18 VGND VGND VPWR VPWR sky130_fd_sc_hd__decap_3
XFILLER_80_29 VGND VGND VPWR VPWR sky130_fd_sc_hd__decap_3
Xfanout24 _6600_/A VGND VGND VPWR VPWR _6570_/A sky130_fd_sc_hd__buf_2
Xfanout35 fanout38/X VGND VGND VPWR VPWR _6639_/A sky130_fd_sc_hd__buf_1
Xfanout46 _6643_/A VGND VGND VPWR VPWR _6522_/A sky130_fd_sc_hd__buf_2
X_6857_ _6936_/CLK _6857_/D VGND VGND VPWR VPWR _6857_/Q sky130_fd_sc_hd__dfxtp_2
XFILLER_22_253 VGND VGND VPWR VPWR sky130_fd_sc_hd__decap_3
Xfanout57 _6288_/A VGND VGND VPWR VPWR _6686_/A sky130_fd_sc_hd__clkdlybuf4s25_1
Xfanout68 fanout72/X VGND VGND VPWR VPWR _6619_/A sky130_fd_sc_hd__clkdlybuf4s25_1
X_6788_ _7390_/CLK _6788_/D VGND VGND VPWR VPWR _6788_/Q sky130_fd_sc_hd__dfxtp_2
XFILLER_108_336 VGND VGND VPWR VPWR sky130_fd_sc_hd__decap_3
XFILLER_89_27 VGND VGND VPWR VPWR sky130_fd_sc_hd__fill_1
XFILLER_89_49 VGND VGND VPWR VPWR sky130_fd_sc_hd__decap_3
XTAP_TAPCELL_ROW_20_487 VGND VPWR sky130_fd_sc_hd__tapvpwrvgnd_1
XFILLER_104_520 VGND VGND VPWR VPWR sky130_fd_sc_hd__decap_3
XFILLER_116_391 VGND VGND VPWR VPWR sky130_fd_sc_hd__fill_1
XFILLER_1_113 VGND VGND VPWR VPWR sky130_fd_sc_hd__decap_3
XFILLER_104_553 VGND VGND VPWR VPWR sky130_fd_sc_hd__decap_3
XFILLER_104_575 VGND VGND VPWR VPWR sky130_fd_sc_hd__decap_3
XFILLER_104_597 VGND VGND VPWR VPWR sky130_fd_sc_hd__decap_3
XFILLER_49_106 VGND VGND VPWR VPWR sky130_fd_sc_hd__fill_2
XFILLER_49_128 VGND VGND VPWR VPWR sky130_fd_sc_hd__decap_3
XFILLER_77_426 VGND VGND VPWR VPWR sky130_fd_sc_hd__decap_3
XFILLER_92_407 VGND VGND VPWR VPWR sky130_fd_sc_hd__decap_3
XFILLER_38_97 VGND VGND VPWR VPWR sky130_fd_sc_hd__decap_3
XFILLER_57_150 VGND VGND VPWR VPWR sky130_fd_sc_hd__decap_3
Xhold1160 _7162_/Q VGND VGND VPWR VPWR _5338_/A0 sky130_fd_sc_hd__dlygate4sd3_1
XFILLER_45_334 VGND VGND VPWR VPWR sky130_fd_sc_hd__fill_2
XFILLER_57_183 VGND VGND VPWR VPWR sky130_fd_sc_hd__decap_3
XFILLER_72_131 VGND VGND VPWR VPWR sky130_fd_sc_hd__decap_3
Xhold1171 _7125_/Q VGND VGND VPWR VPWR _5417_/A0 sky130_fd_sc_hd__dlygate4sd3_1
Xhold1182 _7122_/Q VGND VGND VPWR VPWR _5423_/A0 sky130_fd_sc_hd__dlygate4sd3_1
Xhold1193 _7286_/Q VGND VGND VPWR VPWR _4589_/A sky130_fd_sc_hd__dlygate4sd3_1
XFILLER_54_41 VGND VGND VPWR VPWR sky130_fd_sc_hd__decap_3
XFILLER_60_304 VGND VGND VPWR VPWR sky130_fd_sc_hd__decap_3
XFILLER_73_676 VGND VGND VPWR VPWR sky130_fd_sc_hd__fill_1
XTAP_TAPCELL_ROW_86_1279 VGND VPWR sky130_fd_sc_hd__tapvpwrvgnd_1
XFILLER_45_389 VGND VGND VPWR VPWR sky130_fd_sc_hd__decap_3
XFILLER_60_315 VGND VGND VPWR VPWR sky130_fd_sc_hd__fill_2
XFILLER_60_337 VGND VGND VPWR VPWR sky130_fd_sc_hd__decap_3
XTAP_TAPCELL_ROW_28_587 VGND VPWR sky130_fd_sc_hd__tapvpwrvgnd_1
XFILLER_13_220 VGND VGND VPWR VPWR sky130_fd_sc_hd__decap_3
XFILLER_13_231 VGND VGND VPWR VPWR sky130_fd_sc_hd__decap_3
XFILLER_9_202 VGND VGND VPWR VPWR sky130_fd_sc_hd__decap_3
XFILLER_13_297 VGND VGND VPWR VPWR sky130_fd_sc_hd__decap_3
XFILLER_9_246 VGND VGND VPWR VPWR sky130_fd_sc_hd__decap_3
Xclkload16 _6966_/CLK VGND VGND VPWR VPWR clkload16/X sky130_fd_sc_hd__clkbuf_8
Xclkload27 _7361_/CLK VGND VGND VPWR VPWR clkload27/Y sky130_fd_sc_hd__bufinv_16
Xclkload38 _7403_/CLK VGND VGND VPWR VPWR clkload38/Y sky130_fd_sc_hd__clkinv_2
XFILLER_107_391 VGND VGND VPWR VPWR sky130_fd_sc_hd__fill_1
XFILLER_48_6 VGND VGND VPWR VPWR sky130_fd_sc_hd__decap_3
XFILLER_79_60 VGND VGND VPWR VPWR sky130_fd_sc_hd__decap_3
XFILLER_68_404 VGND VGND VPWR VPWR sky130_fd_sc_hd__decap_3
XFILLER_95_223 VGND VGND VPWR VPWR sky130_fd_sc_hd__fill_1
XFILLER_0_190 VGND VGND VPWR VPWR sky130_fd_sc_hd__decap_3
XFILLER_95_234 VGND VGND VPWR VPWR sky130_fd_sc_hd__decap_3
X_4070_ _7339_/Q _3945_/S _5229_/C _7147_/Q VGND VGND VPWR VPWR _4070_/X sky130_fd_sc_hd__a22o_2
XFILLER_110_578 VGND VGND VPWR VPWR sky130_fd_sc_hd__fill_2
XFILLER_49_673 VGND VGND VPWR VPWR sky130_fd_sc_hd__fill_2
XFILLER_95_267 VGND VGND VPWR VPWR sky130_fd_sc_hd__decap_3
XFILLER_95_92 VGND VGND VPWR VPWR sky130_fd_sc_hd__decap_3
XFILLER_36_312 VGND VGND VPWR VPWR sky130_fd_sc_hd__decap_3
XFILLER_48_183 VGND VGND VPWR VPWR sky130_fd_sc_hd__decap_3
XFILLER_76_492 VGND VGND VPWR VPWR sky130_fd_sc_hd__decap_3
XFILLER_63_142 VGND VGND VPWR VPWR sky130_fd_sc_hd__decap_3
XFILLER_64_687 VGND VGND VPWR VPWR sky130_fd_sc_hd__decap_3
XFILLER_36_389 VGND VGND VPWR VPWR sky130_fd_sc_hd__decap_3
XFILLER_51_326 VGND VGND VPWR VPWR sky130_fd_sc_hd__decap_3
XFILLER_63_197 VGND VGND VPWR VPWR sky130_fd_sc_hd__decap_3
X_4972_ _5661_/B VGND VGND VPWR VPWR _4973_/B sky130_fd_sc_hd__inv_2
XTAP_TAPCELL_ROW_63_1010 VGND VPWR sky130_fd_sc_hd__tapvpwrvgnd_1
X_6711_ _7404_/CLK _6711_/D VGND VGND VPWR VPWR _6711_/Q sky130_fd_sc_hd__dfxtp_2
X_3923_ _3629_/A _3922_/X _5104_/A VGND VGND VPWR VPWR _3923_/X sky130_fd_sc_hd__a21o_2
X_6642_ _6642_/A VGND VGND VPWR VPWR _6642_/Y sky130_fd_sc_hd__inv_2
X_3854_ _3725_/X _3851_/X _3853_/X _3735_/X VGND VGND VPWR VPWR _3854_/X sky130_fd_sc_hd__a22o_2
X_6573_ _6638_/A VGND VGND VPWR VPWR _6573_/Y sky130_fd_sc_hd__inv_2
X_3785_ _6837_/Q _3651_/Y _3890_/B1 _6832_/Q _3784_/X VGND VGND VPWR VPWR _3785_/X
+ sky130_fd_sc_hd__a221o_2
XFILLER_105_306 VGND VGND VPWR VPWR sky130_fd_sc_hd__decap_3
Xoutput510 _3562_/A VGND VGND VPWR VPWR instruction_out[24] sky130_fd_sc_hd__clkdlybuf4s25_1
Xoutput554 _6985_/Q VGND VGND VPWR VPWR pc_out[8] sky130_fd_sc_hd__clkdlybuf4s25_1
Xoutput543 _7004_/Q VGND VGND VPWR VPWR pc_out[27] sky130_fd_sc_hd__clkdlybuf4s25_1
Xoutput532 _6994_/Q VGND VGND VPWR VPWR pc_out[17] sky130_fd_sc_hd__clkdlybuf4s25_1
Xoutput521 _5229_/B VGND VGND VPWR VPWR instruction_out[7] sky130_fd_sc_hd__clkdlybuf4s25_1
X_4406_ _7402_/Q _4437_/B1 _4434_/B1 _7146_/Q _4405_/X VGND VGND VPWR VPWR _4406_/X
+ sky130_fd_sc_hd__a221o_2
XFILLER_5_90 VGND VGND VPWR VPWR sky130_fd_sc_hd__fill_1
X_7125_ clkload4/A _7125_/D _6405_/Y VGND VGND VPWR VPWR _7125_/Q sky130_fd_sc_hd__dfrtp_2
X_5386_ _5386_/A0 _4899_/X _5398_/S VGND VGND VPWR VPWR _7140_/D sky130_fd_sc_hd__mux2_2
XFILLER_101_523 VGND VGND VPWR VPWR sky130_fd_sc_hd__decap_3
XFILLER_113_361 VGND VGND VPWR VPWR sky130_fd_sc_hd__decap_3
XFILLER_115_36 VGND VGND VPWR VPWR sky130_fd_sc_hd__decap_3
XFILLER_59_426 VGND VGND VPWR VPWR sky130_fd_sc_hd__decap_3
XFILLER_86_212 VGND VGND VPWR VPWR sky130_fd_sc_hd__decap_3
X_4337_ _4394_/A _4337_/B _4336_/X VGND VGND VPWR VPWR _4365_/C sky130_fd_sc_hd__or3b_2
XFILLER_99_584 VGND VGND VPWR VPWR sky130_fd_sc_hd__decap_3
XFILLER_75_18 VGND VGND VPWR VPWR sky130_fd_sc_hd__decap_3
XFILLER_86_245 VGND VGND VPWR VPWR sky130_fd_sc_hd__decap_3
XFILLER_86_256 VGND VGND VPWR VPWR sky130_fd_sc_hd__decap_3
X_7056_ clkload5/A _7056_/D _6336_/Y VGND VGND VPWR VPWR _7056_/Q sky130_fd_sc_hd__dfstp_2
X_4268_ _7198_/Q _3968_/S _4354_/B1 _7390_/Q VGND VGND VPWR VPWR _4268_/X sky130_fd_sc_hd__a22o_2
XFILLER_74_418 VGND VGND VPWR VPWR sky130_fd_sc_hd__fill_2
XFILLER_27_334 VGND VGND VPWR VPWR sky130_fd_sc_hd__fill_2
XFILLER_39_172 VGND VGND VPWR VPWR sky130_fd_sc_hd__decap_3
XFILLER_39_194 VGND VGND VPWR VPWR sky130_fd_sc_hd__decap_3
XFILLER_67_481 VGND VGND VPWR VPWR sky130_fd_sc_hd__decap_3
X_4199_ _4380_/A _4380_/B VGND VGND VPWR VPWR _4381_/A sky130_fd_sc_hd__nand2_2
XFILLER_27_367 VGND VGND VPWR VPWR sky130_fd_sc_hd__decap_3
XFILLER_82_451 VGND VGND VPWR VPWR sky130_fd_sc_hd__decap_3
XFILLER_54_186 VGND VGND VPWR VPWR sky130_fd_sc_hd__fill_2
XFILLER_54_197 VGND VGND VPWR VPWR sky130_fd_sc_hd__decap_3
XFILLER_70_613 VGND VGND VPWR VPWR sky130_fd_sc_hd__decap_3
XFILLER_91_28 VGND VGND VPWR VPWR sky130_fd_sc_hd__decap_3
XFILLER_24_11 VGND VGND VPWR VPWR sky130_fd_sc_hd__decap_3
X_6909_ _6909_/CLK _6909_/D VGND VGND VPWR VPWR _6909_/Q sky130_fd_sc_hd__dfxtp_2
XTAP_TAPCELL_ROW_25_557 VGND VPWR sky130_fd_sc_hd__tapvpwrvgnd_1
XTAP_TAPCELL_ROW_25_546 VGND VPWR sky130_fd_sc_hd__tapvpwrvgnd_1
XTAP_TAPCELL_ROW_53_888 VGND VPWR sky130_fd_sc_hd__tapvpwrvgnd_1
XFILLER_24_88 VGND VGND VPWR VPWR sky130_fd_sc_hd__decap_3
XFILLER_50_381 VGND VGND VPWR VPWR sky130_fd_sc_hd__decap_3
XFILLER_108_100 VGND VGND VPWR VPWR sky130_fd_sc_hd__decap_3
XFILLER_109_623 VGND VGND VPWR VPWR sky130_fd_sc_hd__fill_1
XFILLER_10_256 VGND VGND VPWR VPWR sky130_fd_sc_hd__fill_1
XFILLER_10_278 VGND VGND VPWR VPWR sky130_fd_sc_hd__decap_3
XFILLER_40_21 VGND VGND VPWR VPWR sky130_fd_sc_hd__decap_3
XFILLER_40_32 VGND VGND VPWR VPWR sky130_fd_sc_hd__decap_3
XFILLER_108_155 VGND VGND VPWR VPWR sky130_fd_sc_hd__decap_3
XFILLER_108_188 VGND VGND VPWR VPWR sky130_fd_sc_hd__decap_3
XFILLER_49_30 VGND VGND VPWR VPWR sky130_fd_sc_hd__decap_3
XFILLER_49_63 VGND VGND VPWR VPWR sky130_fd_sc_hd__decap_3
XFILLER_104_394 VGND VGND VPWR VPWR sky130_fd_sc_hd__decap_3
XFILLER_77_234 VGND VGND VPWR VPWR sky130_fd_sc_hd__decap_3
XFILLER_1_26 VGND VGND VPWR VPWR sky130_fd_sc_hd__decap_3
XFILLER_37_109 VGND VGND VPWR VPWR sky130_fd_sc_hd__decap_3
XFILLER_65_429 VGND VGND VPWR VPWR sky130_fd_sc_hd__decap_3
XTAP_TAPCELL_ROW_88_1308 VGND VPWR sky130_fd_sc_hd__tapvpwrvgnd_1
XFILLER_18_312 VGND VGND VPWR VPWR sky130_fd_sc_hd__decap_3
XFILLER_92_226 VGND VGND VPWR VPWR sky130_fd_sc_hd__decap_3
XFILLER_45_131 VGND VGND VPWR VPWR sky130_fd_sc_hd__decap_3
XFILLER_46_676 VGND VGND VPWR VPWR sky130_fd_sc_hd__decap_3
XFILLER_65_73 VGND VGND VPWR VPWR sky130_fd_sc_hd__decap_3
XFILLER_73_440 VGND VGND VPWR VPWR sky130_fd_sc_hd__decap_3
XFILLER_33_315 VGND VGND VPWR VPWR sky130_fd_sc_hd__decap_3
XFILLER_33_337 VGND VGND VPWR VPWR sky130_fd_sc_hd__decap_3
XFILLER_45_164 VGND VGND VPWR VPWR sky130_fd_sc_hd__decap_3
XFILLER_60_112 VGND VGND VPWR VPWR sky130_fd_sc_hd__decap_3
XFILLER_65_95 VGND VGND VPWR VPWR sky130_fd_sc_hd__decap_3
XFILLER_73_484 VGND VGND VPWR VPWR sky130_fd_sc_hd__decap_3
XFILLER_61_668 VGND VGND VPWR VPWR sky130_fd_sc_hd__fill_1
XFILLER_60_167 VGND VGND VPWR VPWR sky130_fd_sc_hd__decap_3
XFILLER_81_50 VGND VGND VPWR VPWR sky130_fd_sc_hd__decap_3
XFILLER_81_72 VGND VGND VPWR VPWR sky130_fd_sc_hd__decap_3
XFILLER_81_94 VGND VGND VPWR VPWR sky130_fd_sc_hd__fill_2
XTAP_TAPCELL_ROW_99_1437 VGND VPWR sky130_fd_sc_hd__tapvpwrvgnd_1
X_3570_ _7157_/Q _3409_/X _4337_/B _3469_/B _3339_/Y VGND VGND VPWR VPWR _3570_/X
+ sky130_fd_sc_hd__a2111o_2
XFILLER_5_271 VGND VGND VPWR VPWR sky130_fd_sc_hd__decap_3
X_5240_ _4765_/A _4788_/B _5238_/X _7210_/Q VGND VGND VPWR VPWR _7210_/D sky130_fd_sc_hd__a22o_2
XFILLER_102_309 VGND VGND VPWR VPWR sky130_fd_sc_hd__decap_3
XFILLER_46_3 VGND VGND VPWR VPWR sky130_fd_sc_hd__fill_1
XFILLER_5_293 VGND VGND VPWR VPWR sky130_fd_sc_hd__decap_3
XFILLER_68_212 VGND VGND VPWR VPWR sky130_fd_sc_hd__decap_3
XFILLER_96_510 VGND VGND VPWR VPWR sky130_fd_sc_hd__decap_3
X_5171_ _5171_/A _5190_/B VGND VGND VPWR VPWR _7242_/D sky130_fd_sc_hd__and2_2
XPHY_EDGE_ROW_18_Right_18 VGND VGND VPWR VPWR sky130_fd_sc_hd__decap_3
XFILLER_110_331 VGND VGND VPWR VPWR sky130_fd_sc_hd__decap_3
XFILLER_96_554 VGND VGND VPWR VPWR sky130_fd_sc_hd__decap_3
X_4122_ _7204_/Q _3958_/S _4486_/S _7049_/Q _4121_/X VGND VGND VPWR VPWR _4122_/X
+ sky130_fd_sc_hd__a221o_2
X_4053_ _4054_/A _4456_/A VGND VGND VPWR VPWR _4055_/A sky130_fd_sc_hd__nor2_2
XFILLER_110_386 VGND VGND VPWR VPWR sky130_fd_sc_hd__decap_3
XFILLER_83_237 VGND VGND VPWR VPWR sky130_fd_sc_hd__decap_3
XFILLER_64_462 VGND VGND VPWR VPWR sky130_fd_sc_hd__decap_3
XTAP_TAPCELL_ROW_108_1544 VGND VPWR sky130_fd_sc_hd__tapvpwrvgnd_1
XFILLER_24_315 VGND VGND VPWR VPWR sky130_fd_sc_hd__decap_3
XFILLER_36_164 VGND VGND VPWR VPWR sky130_fd_sc_hd__decap_3
XFILLER_51_101 VGND VGND VPWR VPWR sky130_fd_sc_hd__decap_3
XFILLER_91_281 VGND VGND VPWR VPWR sky130_fd_sc_hd__decap_3
XFILLER_101_49 VGND VGND VPWR VPWR sky130_fd_sc_hd__decap_3
XFILLER_51_145 VGND VGND VPWR VPWR sky130_fd_sc_hd__decap_3
X_4955_ _3604_/B _4639_/A _4950_/A _5033_/B2 VGND VGND VPWR VPWR _4955_/X sky130_fd_sc_hd__a22o_2
XPHY_EDGE_ROW_27_Right_27 VGND VGND VPWR VPWR sky130_fd_sc_hd__decap_3
X_3906_ _6917_/Q _3912_/A2 _3906_/B1 _6691_/Q VGND VGND VPWR VPWR _3906_/X sky130_fd_sc_hd__a22o_2
XTAP_TAPCELL_ROW_22_516 VGND VPWR sky130_fd_sc_hd__tapvpwrvgnd_1
X_4886_ _4886_/A _4890_/B _4886_/C VGND VGND VPWR VPWR _4886_/X sky130_fd_sc_hd__or3_2
XTAP_TAPCELL_ROW_50_847 VGND VPWR sky130_fd_sc_hd__tapvpwrvgnd_1
X_6625_ _6660_/A VGND VGND VPWR VPWR _6625_/Y sky130_fd_sc_hd__inv_2
X_3837_ _6755_/Q _5660_/B _3852_/B1 _6767_/Q VGND VGND VPWR VPWR _3837_/X sky130_fd_sc_hd__a22o_2
X_6556_ _6647_/A VGND VGND VPWR VPWR _6556_/Y sky130_fd_sc_hd__inv_2
X_3768_ _6931_/Q _3859_/A2 _3922_/A2 _6795_/Q VGND VGND VPWR VPWR _3768_/X sky130_fd_sc_hd__a22o_2
XFILLER_106_615 VGND VGND VPWR VPWR sky130_fd_sc_hd__fill_1
XFILLER_106_637 VGND VGND VPWR VPWR sky130_fd_sc_hd__decap_3
XFILLER_106_648 VGND VGND VPWR VPWR sky130_fd_sc_hd__decap_3
XFILLER_10_13 VGND VGND VPWR VPWR sky130_fd_sc_hd__decap_3
XFILLER_10_46 VGND VGND VPWR VPWR sky130_fd_sc_hd__decap_3
XFILLER_3_219 VGND VGND VPWR VPWR sky130_fd_sc_hd__decap_3
X_6487_ _6584_/A VGND VGND VPWR VPWR _6487_/Y sky130_fd_sc_hd__inv_2
X_3699_ _6713_/Q _3863_/A2 _3827_/B1 _6891_/Q VGND VGND VPWR VPWR _3699_/X sky130_fd_sc_hd__a22o_2
XFILLER_105_136 VGND VGND VPWR VPWR sky130_fd_sc_hd__decap_3
XFILLER_105_169 VGND VGND VPWR VPWR sky130_fd_sc_hd__decap_3
XPHY_EDGE_ROW_36_Right_36 VGND VGND VPWR VPWR sky130_fd_sc_hd__decap_3
XFILLER_114_670 VGND VGND VPWR VPWR sky130_fd_sc_hd__fill_1
X_5369_ _5369_/A0 _4752_/X _5383_/S VGND VGND VPWR VPWR _7148_/D sky130_fd_sc_hd__mux2_2
XFILLER_99_370 VGND VGND VPWR VPWR sky130_fd_sc_hd__decap_3
XFILLER_19_11 VGND VGND VPWR VPWR sky130_fd_sc_hd__decap_3
XFILLER_87_532 VGND VGND VPWR VPWR sky130_fd_sc_hd__decap_3
X_7108_ _7330_/CLK _7108_/D _6388_/Y VGND VGND VPWR VPWR _7108_/Q sky130_fd_sc_hd__dfrtp_2
XFILLER_101_375 VGND VGND VPWR VPWR sky130_fd_sc_hd__decap_3
XFILLER_19_109 VGND VGND VPWR VPWR sky130_fd_sc_hd__decap_3
XFILLER_19_55 VGND VGND VPWR VPWR sky130_fd_sc_hd__fill_1
XFILLER_47_429 VGND VGND VPWR VPWR sky130_fd_sc_hd__decap_3
XFILLER_59_278 VGND VGND VPWR VPWR sky130_fd_sc_hd__fill_2
XFILLER_87_576 VGND VGND VPWR VPWR sky130_fd_sc_hd__decap_3
X_7039_ _7394_/CLK _7039_/D _6319_/Y VGND VGND VPWR VPWR _7039_/Q sky130_fd_sc_hd__dfrtp_2
XFILLER_19_66 VGND VGND VPWR VPWR sky130_fd_sc_hd__fill_1
XFILLER_19_77 VGND VGND VPWR VPWR sky130_fd_sc_hd__decap_3
XFILLER_74_215 VGND VGND VPWR VPWR sky130_fd_sc_hd__decap_3
XFILLER_74_248 VGND VGND VPWR VPWR sky130_fd_sc_hd__fill_1
XTAP_TAPCELL_ROW_58_947 VGND VPWR sky130_fd_sc_hd__tapvpwrvgnd_1
XFILLER_27_131 VGND VGND VPWR VPWR sky130_fd_sc_hd__decap_3
XTAP_TAPCELL_ROW_2_274 VGND VPWR sky130_fd_sc_hd__tapvpwrvgnd_1
XFILLER_27_164 VGND VGND VPWR VPWR sky130_fd_sc_hd__decap_3
XFILLER_27_175 VGND VGND VPWR VPWR sky130_fd_sc_hd__decap_3
XFILLER_35_21 VGND VGND VPWR VPWR sky130_fd_sc_hd__decap_3
XFILLER_42_112 VGND VGND VPWR VPWR sky130_fd_sc_hd__decap_3
XFILLER_55_473 VGND VGND VPWR VPWR sky130_fd_sc_hd__decap_3
XFILLER_70_421 VGND VGND VPWR VPWR sky130_fd_sc_hd__decap_3
XPHY_EDGE_ROW_45_Right_45 VGND VGND VPWR VPWR sky130_fd_sc_hd__decap_3
XFILLER_15_337 VGND VGND VPWR VPWR sky130_fd_sc_hd__decap_3
XFILLER_35_76 VGND VGND VPWR VPWR sky130_fd_sc_hd__fill_2
XTAP_TAPCELL_ROW_83_1249 VGND VPWR sky130_fd_sc_hd__tapvpwrvgnd_1
XFILLER_30_307 VGND VGND VPWR VPWR sky130_fd_sc_hd__fill_1
XFILLER_35_87 VGND VGND VPWR VPWR sky130_fd_sc_hd__decap_3
XFILLER_42_178 VGND VGND VPWR VPWR sky130_fd_sc_hd__fill_2
XFILLER_70_465 VGND VGND VPWR VPWR sky130_fd_sc_hd__decap_3
XFILLER_70_498 VGND VGND VPWR VPWR sky130_fd_sc_hd__fill_1
XFILLER_51_53 VGND VGND VPWR VPWR sky130_fd_sc_hd__decap_3
XFILLER_109_431 VGND VGND VPWR VPWR sky130_fd_sc_hd__decap_3
XFILLER_51_75 VGND VGND VPWR VPWR sky130_fd_sc_hd__decap_3
XFILLER_7_558 VGND VGND VPWR VPWR sky130_fd_sc_hd__fill_2
XPHY_EDGE_ROW_54_Right_54 VGND VGND VPWR VPWR sky130_fd_sc_hd__decap_3
XTAP_TAPCELL_ROW_94_1378 VGND VPWR sky130_fd_sc_hd__tapvpwrvgnd_1
XFILLER_105_681 VGND VGND VPWR VPWR sky130_fd_sc_hd__fill_1
XFILLER_32_9 VGND VGND VPWR VPWR sky130_fd_sc_hd__decap_3
XFILLER_2_296 VGND VGND VPWR VPWR sky130_fd_sc_hd__decap_3
XFILLER_76_50 VGND VGND VPWR VPWR sky130_fd_sc_hd__decap_3
XFILLER_93_502 VGND VGND VPWR VPWR sky130_fd_sc_hd__fill_2
XFILLER_65_237 VGND VGND VPWR VPWR sky130_fd_sc_hd__fill_1
XFILLER_78_598 VGND VGND VPWR VPWR sky130_fd_sc_hd__decap_3
XFILLER_65_248 VGND VGND VPWR VPWR sky130_fd_sc_hd__decap_3
XFILLER_80_207 VGND VGND VPWR VPWR sky130_fd_sc_hd__decap_3
XFILLER_93_557 VGND VGND VPWR VPWR sky130_fd_sc_hd__decap_3
XPHY_EDGE_ROW_63_Right_63 VGND VGND VPWR VPWR sky130_fd_sc_hd__decap_3
XFILLER_18_175 VGND VGND VPWR VPWR sky130_fd_sc_hd__decap_3
XFILLER_18_197 VGND VGND VPWR VPWR sky130_fd_sc_hd__decap_3
XFILLER_61_432 VGND VGND VPWR VPWR sky130_fd_sc_hd__decap_3
XFILLER_73_281 VGND VGND VPWR VPWR sky130_fd_sc_hd__decap_3
XFILLER_21_307 VGND VGND VPWR VPWR sky130_fd_sc_hd__decap_3
XFILLER_33_156 VGND VGND VPWR VPWR sky130_fd_sc_hd__fill_1
XFILLER_33_178 VGND VGND VPWR VPWR sky130_fd_sc_hd__decap_3
XFILLER_92_82 VGND VGND VPWR VPWR sky130_fd_sc_hd__fill_2
X_4740_ _4610_/A _4765_/B _4611_/Y _4762_/A _4948_/A VGND VGND VPWR VPWR _4740_/X
+ sky130_fd_sc_hd__a221o_2
XTAP_TAPCELL_ROW_103_1485 VGND VPWR sky130_fd_sc_hd__tapvpwrvgnd_1
X_4671_ _6991_/Q _4671_/B VGND VGND VPWR VPWR _4982_/B sky130_fd_sc_hd__and2_2
X_7390_ _7390_/CLK _7390_/D _6670_/Y VGND VGND VPWR VPWR _7390_/Q sky130_fd_sc_hd__dfrtp_2
X_6410_ _6539_/A VGND VGND VPWR VPWR _6410_/Y sky130_fd_sc_hd__inv_2
X_3622_ _4852_/A _5057_/A VGND VGND VPWR VPWR _3635_/B sky130_fd_sc_hd__nand2_2
X_6341_ _6347_/A VGND VGND VPWR VPWR _6341_/Y sky130_fd_sc_hd__inv_2
XPHY_EDGE_ROW_72_Right_72 VGND VGND VPWR VPWR sky130_fd_sc_hd__decap_3
XFILLER_115_423 VGND VGND VPWR VPWR sky130_fd_sc_hd__fill_2
X_3553_ _3469_/A _3469_/B _3449_/A _7253_/Q _3365_/A VGND VGND VPWR VPWR _3553_/X
+ sky130_fd_sc_hd__o2111a_2
XFILLER_103_607 VGND VGND VPWR VPWR sky130_fd_sc_hd__fill_1
X_6272_ _6523_/A VGND VGND VPWR VPWR _6272_/Y sky130_fd_sc_hd__inv_2
X_3484_ _4394_/A _3449_/X _3482_/Y _5153_/B VGND VGND VPWR VPWR _3485_/C sky130_fd_sc_hd__o31a_2
XFILLER_102_106 VGND VGND VPWR VPWR sky130_fd_sc_hd__decap_3
XFILLER_103_629 VGND VGND VPWR VPWR sky130_fd_sc_hd__decap_3
XFILLER_88_318 VGND VGND VPWR VPWR sky130_fd_sc_hd__decap_3
X_5223_ _5223_/A _5225_/B VGND VGND VPWR VPWR _7217_/D sky130_fd_sc_hd__and2_2
XFILLER_69_532 VGND VGND VPWR VPWR sky130_fd_sc_hd__decap_3
X_5154_ _5152_/Y _5153_/X _5587_/B VGND VGND VPWR VPWR _5154_/Y sky130_fd_sc_hd__a21oi_2
XFILLER_111_673 VGND VGND VPWR VPWR sky130_fd_sc_hd__fill_1
XFILLER_84_513 VGND VGND VPWR VPWR sky130_fd_sc_hd__decap_3
XFILLER_96_351 VGND VGND VPWR VPWR sky130_fd_sc_hd__decap_3
X_4105_ _7205_/Q _4414_/B1 _4419_/B1 _7397_/Q _4104_/X VGND VGND VPWR VPWR _4105_/X
+ sky130_fd_sc_hd__a221o_2
XPHY_EDGE_ROW_16_Left_133 VGND VGND VPWR VPWR sky130_fd_sc_hd__decap_3
XFILLER_56_215 VGND VGND VPWR VPWR sky130_fd_sc_hd__decap_3
X_5085_ _5086_/A _5084_/B _5084_/X VGND VGND VPWR VPWR _5085_/X sky130_fd_sc_hd__o21ba_2
XPHY_EDGE_ROW_81_Right_81 VGND VGND VPWR VPWR sky130_fd_sc_hd__decap_3
XFILLER_56_248 VGND VGND VPWR VPWR sky130_fd_sc_hd__decap_3
XFILLER_56_259 VGND VGND VPWR VPWR sky130_fd_sc_hd__decap_3
XFILLER_84_579 VGND VGND VPWR VPWR sky130_fd_sc_hd__decap_3
X_4036_ _7310_/Q _4793_/S _4434_/A2 _7118_/Q _4035_/X VGND VGND VPWR VPWR _4036_/X
+ sky130_fd_sc_hd__a221o_2
XTAP_TAPCELL_ROW_55_917 VGND VPWR sky130_fd_sc_hd__tapvpwrvgnd_1
XTAP_TAPCELL_ROW_55_906 VGND VPWR sky130_fd_sc_hd__tapvpwrvgnd_1
XFILLER_112_59 VGND VGND VPWR VPWR sky130_fd_sc_hd__decap_3
XFILLER_24_101 VGND VGND VPWR VPWR sky130_fd_sc_hd__decap_3
XFILLER_24_134 VGND VGND VPWR VPWR sky130_fd_sc_hd__decap_3
XFILLER_37_495 VGND VGND VPWR VPWR sky130_fd_sc_hd__decap_3
XTAP_TAPCELL_ROW_69_1082 VGND VPWR sky130_fd_sc_hd__tapvpwrvgnd_1
XFILLER_12_307 VGND VGND VPWR VPWR sky130_fd_sc_hd__fill_1
XFILLER_12_318 VGND VGND VPWR VPWR sky130_fd_sc_hd__decap_3
XFILLER_24_156 VGND VGND VPWR VPWR sky130_fd_sc_hd__decap_3
XTAP_TAPCELL_ROW_35_674 VGND VPWR sky130_fd_sc_hd__tapvpwrvgnd_1
XFILLER_24_189 VGND VGND VPWR VPWR sky130_fd_sc_hd__decap_3
XFILLER_33_690 VGND VGND VPWR VPWR sky130_fd_sc_hd__fill_2
XFILLER_52_498 VGND VGND VPWR VPWR sky130_fd_sc_hd__decap_3
X_4938_ _4938_/A _4938_/B VGND VGND VPWR VPWR _4938_/Y sky130_fd_sc_hd__nor2_2
XANTENNA_30 _5661_/D VGND VGND VPWR VPWR sky130_fd_sc_hd__diode_2
XFILLER_20_351 VGND VGND VPWR VPWR sky130_fd_sc_hd__decap_3
X_4869_ _6999_/Q _4858_/B _4983_/A VGND VGND VPWR VPWR _4870_/B sky130_fd_sc_hd__o21ai_2
XPHY_EDGE_ROW_25_Left_142 VGND VGND VPWR VPWR sky130_fd_sc_hd__decap_3
X_6608_ _6608_/A VGND VGND VPWR VPWR _6608_/Y sky130_fd_sc_hd__inv_2
XPHY_EDGE_ROW_90_Right_90 VGND VGND VPWR VPWR sky130_fd_sc_hd__decap_3
XFILLER_21_89 VGND VGND VPWR VPWR sky130_fd_sc_hd__decap_3
X_6539_ _6539_/A VGND VGND VPWR VPWR _6539_/Y sky130_fd_sc_hd__inv_2
XFILLER_106_445 VGND VGND VPWR VPWR sky130_fd_sc_hd__decap_3
XFILLER_97_27 VGND VGND VPWR VPWR sky130_fd_sc_hd__decap_3
XTAP_TAPCELL_ROW_7_333 VGND VPWR sky130_fd_sc_hd__tapvpwrvgnd_1
XPHY_EDGE_ROW_34_Left_151 VGND VGND VPWR VPWR sky130_fd_sc_hd__decap_3
XFILLER_102_651 VGND VGND VPWR VPWR sky130_fd_sc_hd__decap_3
XFILLER_87_340 VGND VGND VPWR VPWR sky130_fd_sc_hd__decap_3
XFILLER_87_373 VGND VGND VPWR VPWR sky130_fd_sc_hd__decap_3
XFILLER_47_237 VGND VGND VPWR VPWR sky130_fd_sc_hd__decap_3
XFILLER_75_546 VGND VGND VPWR VPWR sky130_fd_sc_hd__decap_3
XFILLER_75_579 VGND VGND VPWR VPWR sky130_fd_sc_hd__decap_3
XFILLER_16_613 VGND VGND VPWR VPWR sky130_fd_sc_hd__fill_2
XFILLER_28_473 VGND VGND VPWR VPWR sky130_fd_sc_hd__decap_3
XFILLER_62_207 VGND VGND VPWR VPWR sky130_fd_sc_hd__decap_3
XFILLER_55_281 VGND VGND VPWR VPWR sky130_fd_sc_hd__fill_1
XFILLER_102_70 VGND VGND VPWR VPWR sky130_fd_sc_hd__decap_3
XFILLER_15_156 VGND VGND VPWR VPWR sky130_fd_sc_hd__decap_3
XFILLER_15_178 VGND VGND VPWR VPWR sky130_fd_sc_hd__decap_3
XFILLER_70_262 VGND VGND VPWR VPWR sky130_fd_sc_hd__decap_3
XFILLER_24_690 VGND VGND VPWR VPWR sky130_fd_sc_hd__fill_2
XFILLER_30_126 VGND VGND VPWR VPWR sky130_fd_sc_hd__decap_3
XFILLER_43_498 VGND VGND VPWR VPWR sky130_fd_sc_hd__decap_3
XFILLER_62_41 VGND VGND VPWR VPWR sky130_fd_sc_hd__fill_1
XFILLER_62_52 VGND VGND VPWR VPWR sky130_fd_sc_hd__decap_3
XPHY_EDGE_ROW_43_Left_160 VGND VGND VPWR VPWR sky130_fd_sc_hd__decap_3
XFILLER_11_340 VGND VGND VPWR VPWR sky130_fd_sc_hd__decap_3
XFILLER_30_159 VGND VGND VPWR VPWR sky130_fd_sc_hd__decap_3
XFILLER_62_85 VGND VGND VPWR VPWR sky130_fd_sc_hd__decap_3
XFILLER_7_311 VGND VGND VPWR VPWR sky130_fd_sc_hd__decap_3
XTAP_TAPCELL_ROW_96_1407 VGND VPWR sky130_fd_sc_hd__tapvpwrvgnd_1
XFILLER_7_355 VGND VGND VPWR VPWR sky130_fd_sc_hd__decap_3
XFILLER_7_69 VGND VGND VPWR VPWR sky130_fd_sc_hd__decap_3
XFILLER_109_261 VGND VGND VPWR VPWR sky130_fd_sc_hd__decap_3
XFILLER_98_605 VGND VGND VPWR VPWR sky130_fd_sc_hd__decap_3
XFILLER_112_404 VGND VGND VPWR VPWR sky130_fd_sc_hd__decap_3
XFILLER_3_561 VGND VGND VPWR VPWR sky130_fd_sc_hd__fill_1
XFILLER_30_6 VGND VGND VPWR VPWR sky130_fd_sc_hd__fill_2
XFILLER_87_60 VGND VGND VPWR VPWR sky130_fd_sc_hd__decap_3
XFILLER_97_137 VGND VGND VPWR VPWR sky130_fd_sc_hd__decap_3
XFILLER_66_513 VGND VGND VPWR VPWR sky130_fd_sc_hd__decap_3
XFILLER_78_395 VGND VGND VPWR VPWR sky130_fd_sc_hd__decap_3
XFILLER_93_310 VGND VGND VPWR VPWR sky130_fd_sc_hd__decap_3
XFILLER_38_248 VGND VGND VPWR VPWR sky130_fd_sc_hd__decap_3
XFILLER_38_259 VGND VGND VPWR VPWR sky130_fd_sc_hd__decap_3
XFILLER_93_343 VGND VGND VPWR VPWR sky130_fd_sc_hd__decap_3
XFILLER_53_207 VGND VGND VPWR VPWR sky130_fd_sc_hd__decap_3
XFILLER_81_538 VGND VGND VPWR VPWR sky130_fd_sc_hd__decap_3
XFILLER_93_376 VGND VGND VPWR VPWR sky130_fd_sc_hd__decap_3
XTAP_TAPCELL_ROW_105_1514 VGND VPWR sky130_fd_sc_hd__tapvpwrvgnd_1
XFILLER_34_421 VGND VGND VPWR VPWR sky130_fd_sc_hd__fill_1
X_6890_ _7404_/CLK _6890_/D VGND VGND VPWR VPWR _6890_/Q sky130_fd_sc_hd__dfxtp_2
XFILLER_61_262 VGND VGND VPWR VPWR sky130_fd_sc_hd__decap_3
XFILLER_15_690 VGND VGND VPWR VPWR sky130_fd_sc_hd__fill_2
XFILLER_21_104 VGND VGND VPWR VPWR sky130_fd_sc_hd__decap_3
XTAP_TAPCELL_ROW_32_633 VGND VPWR sky130_fd_sc_hd__tapvpwrvgnd_1
XFILLER_21_148 VGND VGND VPWR VPWR sky130_fd_sc_hd__decap_3
X_4723_ _3536_/B _4720_/A _4721_/Y _4891_/A1 VGND VGND VPWR VPWR _4723_/X sky130_fd_sc_hd__a22o_2
XTAP_TAPCELL_ROW_60_975 VGND VPWR sky130_fd_sc_hd__tapvpwrvgnd_1
X_4654_ _4646_/Y _4647_/X _4653_/Y _4788_/B VGND VGND VPWR VPWR _4762_/A sky130_fd_sc_hd__a211o_2
XTAP_TAPCELL_ROW_12_390 VGND VPWR sky130_fd_sc_hd__tapvpwrvgnd_1
X_7373_ _7403_/CLK _7373_/D _6653_/Y VGND VGND VPWR VPWR _7373_/Q sky130_fd_sc_hd__dfrtp_2
Xhold801 _6740_/Q VGND VGND VPWR VPWR _6740_/D sky130_fd_sc_hd__dlygate4sd3_1
Xhold812 _6935_/Q VGND VGND VPWR VPWR _6935_/D sky130_fd_sc_hd__dlygate4sd3_1
X_4585_ _4585_/A _4595_/B VGND VGND VPWR VPWR _7288_/D sky130_fd_sc_hd__and2_2
X_3605_ _3621_/A _3621_/B VGND VGND VPWR VPWR _3605_/Y sky130_fd_sc_hd__nor2b_2
XTAP_TAPCELL_ROW_116_1643 VGND VPWR sky130_fd_sc_hd__tapvpwrvgnd_1
XFILLER_115_231 VGND VGND VPWR VPWR sky130_fd_sc_hd__decap_3
Xhold823 _6731_/Q VGND VGND VPWR VPWR _6731_/D sky130_fd_sc_hd__dlygate4sd3_1
Xhold834 _6943_/Q VGND VGND VPWR VPWR _6943_/D sky130_fd_sc_hd__dlygate4sd3_1
Xhold845 _6806_/Q VGND VGND VPWR VPWR _6806_/D sky130_fd_sc_hd__dlygate4sd3_1
X_6324_ _6642_/A VGND VGND VPWR VPWR _6324_/Y sky130_fd_sc_hd__inv_2
X_3536_ _4614_/A _3536_/B VGND VGND VPWR VPWR _3536_/Y sky130_fd_sc_hd__nand2_2
XTAP_TAPCELL_ROW_116_1654 VGND VPWR sky130_fd_sc_hd__tapvpwrvgnd_1
XFILLER_107_26 VGND VGND VPWR VPWR sky130_fd_sc_hd__decap_3
XFILLER_89_638 VGND VGND VPWR VPWR sky130_fd_sc_hd__decap_3
Xhold856 _7104_/Q VGND VGND VPWR VPWR _7104_/D sky130_fd_sc_hd__dlygate4sd3_1
Xhold867 _7111_/Q VGND VGND VPWR VPWR _7111_/D sky130_fd_sc_hd__dlygate4sd3_1
Xhold878 _7094_/Q VGND VGND VPWR VPWR _7094_/D sky130_fd_sc_hd__dlygate4sd3_1
Xhold889 _7117_/Q VGND VGND VPWR VPWR _7117_/D sky130_fd_sc_hd__dlygate4sd3_1
Xmax_cap575 _6585_/A VGND VGND VPWR VPWR _6617_/A sky130_fd_sc_hd__buf_2
Xmax_cap564 _4994_/A2 VGND VGND VPWR VPWR _4275_/A sky130_fd_sc_hd__clkdlybuf4s25_1
XFILLER_103_437 VGND VGND VPWR VPWR sky130_fd_sc_hd__decap_3
XFILLER_88_126 VGND VGND VPWR VPWR sky130_fd_sc_hd__decap_3
X_3467_ _7121_/Q _3407_/X _4334_/B1 _7153_/Q _3466_/X VGND VGND VPWR VPWR _3467_/X
+ sky130_fd_sc_hd__a221o_2
XFILLER_88_159 VGND VGND VPWR VPWR sky130_fd_sc_hd__decap_3
X_3398_ _4522_/S VGND VGND VPWR VPWR _3398_/Y sky130_fd_sc_hd__inv_2
XTAP_TAPCELL_ROW_4_303 VGND VPWR sky130_fd_sc_hd__tapvpwrvgnd_1
XFILLER_97_671 VGND VGND VPWR VPWR sky130_fd_sc_hd__fill_1
XFILLER_69_384 VGND VGND VPWR VPWR sky130_fd_sc_hd__decap_3
XFILLER_29_248 VGND VGND VPWR VPWR sky130_fd_sc_hd__decap_3
XFILLER_57_579 VGND VGND VPWR VPWR sky130_fd_sc_hd__decap_3
XFILLER_84_332 VGND VGND VPWR VPWR sky130_fd_sc_hd__decap_3
XFILLER_96_192 VGND VGND VPWR VPWR sky130_fd_sc_hd__decap_3
X_5068_ _6985_/Q _6986_/Q _5068_/C VGND VGND VPWR VPWR _5069_/B sky130_fd_sc_hd__and3_2
XFILLER_44_218 VGND VGND VPWR VPWR sky130_fd_sc_hd__decap_3
XFILLER_83_29 VGND VGND VPWR VPWR sky130_fd_sc_hd__decap_3
XFILLER_84_365 VGND VGND VPWR VPWR sky130_fd_sc_hd__decap_3
X_4019_ _7278_/Q _4437_/A2 _4430_/A2 _7246_/Q _4018_/X VGND VGND VPWR VPWR _4019_/X
+ sky130_fd_sc_hd__a221o_2
XFILLER_16_12 VGND VGND VPWR VPWR sky130_fd_sc_hd__decap_3
XFILLER_37_281 VGND VGND VPWR VPWR sky130_fd_sc_hd__decap_3
XFILLER_16_45 VGND VGND VPWR VPWR sky130_fd_sc_hd__decap_3
XFILLER_16_78 VGND VGND VPWR VPWR sky130_fd_sc_hd__decap_3
XFILLER_25_476 VGND VGND VPWR VPWR sky130_fd_sc_hd__decap_3
XFILLER_40_402 VGND VGND VPWR VPWR sky130_fd_sc_hd__decap_3
XFILLER_52_262 VGND VGND VPWR VPWR sky130_fd_sc_hd__decap_3
XTAP_TAPCELL_ROW_80_1208 VGND VPWR sky130_fd_sc_hd__tapvpwrvgnd_1
XPHY_EDGE_ROW_0_Right_0 VGND VGND VPWR VPWR sky130_fd_sc_hd__decap_3
XFILLER_40_424 VGND VGND VPWR VPWR sky130_fd_sc_hd__decap_3
XFILLER_21_671 VGND VGND VPWR VPWR sky130_fd_sc_hd__fill_1
XFILLER_32_88 VGND VGND VPWR VPWR sky130_fd_sc_hd__fill_2
XFILLER_106_231 VGND VGND VPWR VPWR sky130_fd_sc_hd__decap_3
XFILLER_4_336 VGND VGND VPWR VPWR sky130_fd_sc_hd__decap_3
XFILLER_106_253 VGND VGND VPWR VPWR sky130_fd_sc_hd__decap_3
XFILLER_79_104 VGND VGND VPWR VPWR sky130_fd_sc_hd__decap_3
XFILLER_106_297 VGND VGND VPWR VPWR sky130_fd_sc_hd__decap_3
XFILLER_79_137 VGND VGND VPWR VPWR sky130_fd_sc_hd__decap_3
XTAP_TAPCELL_ROW_91_1348 VGND VPWR sky130_fd_sc_hd__tapvpwrvgnd_1
XFILLER_88_671 VGND VGND VPWR VPWR sky130_fd_sc_hd__decap_3
XFILLER_102_470 VGND VGND VPWR VPWR sky130_fd_sc_hd__decap_3
XFILLER_57_30 VGND VGND VPWR VPWR sky130_fd_sc_hd__fill_2
XFILLER_57_63 VGND VGND VPWR VPWR sky130_fd_sc_hd__decap_3
XFILLER_57_96 VGND VGND VPWR VPWR sky130_fd_sc_hd__fill_1
XFILLER_75_343 VGND VGND VPWR VPWR sky130_fd_sc_hd__fill_1
XFILLER_35_207 VGND VGND VPWR VPWR sky130_fd_sc_hd__decap_3
XFILLER_63_516 VGND VGND VPWR VPWR sky130_fd_sc_hd__decap_3
XFILLER_16_410 VGND VGND VPWR VPWR sky130_fd_sc_hd__decap_3
XFILLER_16_421 VGND VGND VPWR VPWR sky130_fd_sc_hd__decap_3
XFILLER_63_549 VGND VGND VPWR VPWR sky130_fd_sc_hd__decap_3
XFILLER_73_40 VGND VGND VPWR VPWR sky130_fd_sc_hd__decap_3
XFILLER_90_324 VGND VGND VPWR VPWR sky130_fd_sc_hd__decap_3
XFILLER_90_357 VGND VGND VPWR VPWR sky130_fd_sc_hd__decap_3
XFILLER_16_454 VGND VGND VPWR VPWR sky130_fd_sc_hd__fill_2
XFILLER_31_402 VGND VGND VPWR VPWR sky130_fd_sc_hd__decap_3
XFILLER_43_251 VGND VGND VPWR VPWR sky130_fd_sc_hd__decap_3
XFILLER_90_368 VGND VGND VPWR VPWR sky130_fd_sc_hd__decap_3
XFILLER_31_424 VGND VGND VPWR VPWR sky130_fd_sc_hd__fill_1
XFILLER_43_284 VGND VGND VPWR VPWR sky130_fd_sc_hd__decap_3
XFILLER_71_582 VGND VGND VPWR VPWR sky130_fd_sc_hd__decap_3
XFILLER_73_84 VGND VGND VPWR VPWR sky130_fd_sc_hd__decap_3
XFILLER_31_446 VGND VGND VPWR VPWR sky130_fd_sc_hd__fill_2
XFILLER_31_457 VGND VGND VPWR VPWR sky130_fd_sc_hd__fill_1
XTAP_TAPCELL_ROW_100_1455 VGND VPWR sky130_fd_sc_hd__tapvpwrvgnd_1
XFILLER_8_653 VGND VGND VPWR VPWR sky130_fd_sc_hd__decap_3
XFILLER_7_163 VGND VGND VPWR VPWR sky130_fd_sc_hd__decap_3
XFILLER_8_675 VGND VGND VPWR VPWR sky130_fd_sc_hd__fill_1
XFILLER_7_196 VGND VGND VPWR VPWR sky130_fd_sc_hd__decap_3
X_4370_ _5100_/B _4361_/X _4362_/X _4369_/Y VGND VGND VPWR VPWR _5032_/B sky130_fd_sc_hd__a211o_2
X_3321_ _3327_/A _3353_/A VGND VGND VPWR VPWR _5294_/A sky130_fd_sc_hd__or2_4
XFILLER_112_212 VGND VGND VPWR VPWR sky130_fd_sc_hd__decap_3
XFILLER_98_424 VGND VGND VPWR VPWR sky130_fd_sc_hd__decap_3
XFILLER_100_407 VGND VGND VPWR VPWR sky130_fd_sc_hd__decap_3
XFILLER_112_256 VGND VGND VPWR VPWR sky130_fd_sc_hd__decap_3
XFILLER_98_468 VGND VGND VPWR VPWR sky130_fd_sc_hd__decap_3
XFILLER_112_289 VGND VGND VPWR VPWR sky130_fd_sc_hd__decap_3
XFILLER_39_513 VGND VGND VPWR VPWR sky130_fd_sc_hd__fill_1
XFILLER_78_170 VGND VGND VPWR VPWR sky130_fd_sc_hd__decap_3
XFILLER_94_630 VGND VGND VPWR VPWR sky130_fd_sc_hd__decap_3
XTAP_TAPCELL_ROW_111_1584 VGND VPWR sky130_fd_sc_hd__tapvpwrvgnd_1
XFILLER_66_332 VGND VGND VPWR VPWR sky130_fd_sc_hd__decap_3
XFILLER_26_218 VGND VGND VPWR VPWR sky130_fd_sc_hd__fill_1
XFILLER_66_365 VGND VGND VPWR VPWR sky130_fd_sc_hd__decap_3
XFILLER_19_281 VGND VGND VPWR VPWR sky130_fd_sc_hd__decap_3
XFILLER_81_335 VGND VGND VPWR VPWR sky130_fd_sc_hd__fill_1
XFILLER_81_346 VGND VGND VPWR VPWR sky130_fd_sc_hd__decap_3
X_6942_ _6965_/CLK _6942_/D VGND VGND VPWR VPWR _6942_/Q sky130_fd_sc_hd__dfxtp_2
XFILLER_81_379 VGND VGND VPWR VPWR sky130_fd_sc_hd__decap_3
X_6873_ _6929_/CLK _6873_/D VGND VGND VPWR VPWR _6873_/Q sky130_fd_sc_hd__dfxtp_2
XTAP_TAPCELL_ROW_66_1041 VGND VPWR sky130_fd_sc_hd__tapvpwrvgnd_1
XFILLER_22_413 VGND VGND VPWR VPWR sky130_fd_sc_hd__decap_3
XFILLER_22_424 VGND VGND VPWR VPWR sky130_fd_sc_hd__decap_3
XFILLER_34_262 VGND VGND VPWR VPWR sky130_fd_sc_hd__decap_3
XFILLER_62_582 VGND VGND VPWR VPWR sky130_fd_sc_hd__decap_3
XTAP_TAPCELL_ROW_45_791 VGND VPWR sky130_fd_sc_hd__tapvpwrvgnd_1
XTAP_TAPCELL_ROW_17_460 VGND VPWR sky130_fd_sc_hd__tapvpwrvgnd_1
XFILLER_34_295 VGND VGND VPWR VPWR sky130_fd_sc_hd__decap_3
X_5686_ _7349_/Q hold936/X _5706_/S VGND VGND VPWR VPWR _5686_/X sky130_fd_sc_hd__mux2_2
X_4706_ _6997_/Q _4931_/A VGND VGND VPWR VPWR _4912_/A sky130_fd_sc_hd__and2_2
X_4637_ _4380_/B _4637_/B _4637_/C VGND VGND VPWR VPWR _4950_/B sky130_fd_sc_hd__and3b_2
Xhold620 _6870_/Q VGND VGND VPWR VPWR _6870_/D sky130_fd_sc_hd__dlygate4sd3_1
XFILLER_116_551 VGND VGND VPWR VPWR sky130_fd_sc_hd__decap_3
XFILLER_78_29 VGND VGND VPWR VPWR sky130_fd_sc_hd__decap_3
XFILLER_89_402 VGND VGND VPWR VPWR sky130_fd_sc_hd__decap_3
X_7356_ _7394_/CLK _7356_/D _6636_/Y VGND VGND VPWR VPWR _7356_/Q sky130_fd_sc_hd__dfrtp_2
Xhold631 _6957_/Q VGND VGND VPWR VPWR _6957_/D sky130_fd_sc_hd__dlygate4sd3_1
Xhold642 _6890_/Q VGND VGND VPWR VPWR _6890_/D sky130_fd_sc_hd__dlygate4sd3_1
Xhold653 _6872_/Q VGND VGND VPWR VPWR _6872_/D sky130_fd_sc_hd__dlygate4sd3_1
XTAP_TAPCELL_ROW_77_1181 VGND VPWR sky130_fd_sc_hd__tapvpwrvgnd_1
XTAP_TAPCELL_ROW_77_1170 VGND VPWR sky130_fd_sc_hd__tapvpwrvgnd_1
XFILLER_103_223 VGND VGND VPWR VPWR sky130_fd_sc_hd__fill_1
XFILLER_103_234 VGND VGND VPWR VPWR sky130_fd_sc_hd__decap_3
XFILLER_116_595 VGND VGND VPWR VPWR sky130_fd_sc_hd__decap_3
XFILLER_89_435 VGND VGND VPWR VPWR sky130_fd_sc_hd__decap_3
X_7287_ clkload8/A _7287_/D _6567_/Y VGND VGND VPWR VPWR _7287_/Q sky130_fd_sc_hd__dfrtp_2
Xhold664 _6794_/Q VGND VGND VPWR VPWR _6794_/D sky130_fd_sc_hd__dlygate4sd3_1
Xhold675 _6945_/Q VGND VGND VPWR VPWR _6945_/D sky130_fd_sc_hd__dlygate4sd3_1
Xhold686 _6908_/Q VGND VGND VPWR VPWR _6908_/D sky130_fd_sc_hd__dlygate4sd3_1
Xhold697 _6800_/Q VGND VGND VPWR VPWR _6800_/D sky130_fd_sc_hd__dlygate4sd3_1
X_6307_ _6617_/A VGND VGND VPWR VPWR _6307_/Y sky130_fd_sc_hd__inv_2
X_4499_ _4499_/A0 _7298_/Q _4501_/S VGND VGND VPWR VPWR _7330_/D sky130_fd_sc_hd__mux2_2
X_3519_ _6979_/Q _3519_/B VGND VGND VPWR VPWR _3519_/Y sky130_fd_sc_hd__nor2_2
XFILLER_89_479 VGND VGND VPWR VPWR sky130_fd_sc_hd__decap_3
XFILLER_57_332 VGND VGND VPWR VPWR sky130_fd_sc_hd__decap_3
XFILLER_57_343 VGND VGND VPWR VPWR sky130_fd_sc_hd__decap_3
XFILLER_69_181 VGND VGND VPWR VPWR sky130_fd_sc_hd__decap_3
XFILLER_85_652 VGND VGND VPWR VPWR sky130_fd_sc_hd__decap_3
XFILLER_27_22 VGND VGND VPWR VPWR sky130_fd_sc_hd__decap_3
XFILLER_27_44 VGND VGND VPWR VPWR sky130_fd_sc_hd__decap_3
XFILLER_45_505 VGND VGND VPWR VPWR sky130_fd_sc_hd__decap_3
XFILLER_45_527 VGND VGND VPWR VPWR sky130_fd_sc_hd__decap_3
XFILLER_57_376 VGND VGND VPWR VPWR sky130_fd_sc_hd__decap_3
XFILLER_27_66 VGND VGND VPWR VPWR sky130_fd_sc_hd__decap_3
XFILLER_25_251 VGND VGND VPWR VPWR sky130_fd_sc_hd__decap_3
XFILLER_72_357 VGND VGND VPWR VPWR sky130_fd_sc_hd__decap_3
XFILLER_72_368 VGND VGND VPWR VPWR sky130_fd_sc_hd__decap_3
XFILLER_13_413 VGND VGND VPWR VPWR sky130_fd_sc_hd__decap_3
XFILLER_25_284 VGND VGND VPWR VPWR sky130_fd_sc_hd__decap_3
XFILLER_43_32 VGND VGND VPWR VPWR sky130_fd_sc_hd__decap_3
XFILLER_13_446 VGND VGND VPWR VPWR sky130_fd_sc_hd__fill_2
XFILLER_40_232 VGND VGND VPWR VPWR sky130_fd_sc_hd__decap_3
XFILLER_40_265 VGND VGND VPWR VPWR sky130_fd_sc_hd__decap_3
XFILLER_9_428 VGND VGND VPWR VPWR sky130_fd_sc_hd__decap_3
Xclkbuf_leaf_20_clk clkbuf_3_6__f_clk/X VGND VGND VPWR VPWR _7401_/CLK sky130_fd_sc_hd__clkbuf_16
XFILLER_107_540 VGND VGND VPWR VPWR sky130_fd_sc_hd__decap_3
XFILLER_4_144 VGND VGND VPWR VPWR sky130_fd_sc_hd__decap_3
XFILLER_4_155 VGND VGND VPWR VPWR sky130_fd_sc_hd__decap_3
XFILLER_108_80 VGND VGND VPWR VPWR sky130_fd_sc_hd__decap_3
XFILLER_4_188 VGND VGND VPWR VPWR sky130_fd_sc_hd__decap_3
XFILLER_4_26 VGND VGND VPWR VPWR sky130_fd_sc_hd__fill_2
XFILLER_4_48 VGND VGND VPWR VPWR sky130_fd_sc_hd__decap_3
XFILLER_108_91 VGND VGND VPWR VPWR sky130_fd_sc_hd__decap_3
XFILLER_68_62 VGND VGND VPWR VPWR sky130_fd_sc_hd__decap_3
XFILLER_95_405 VGND VGND VPWR VPWR sky130_fd_sc_hd__decap_3
XFILLER_0_350 VGND VGND VPWR VPWR sky130_fd_sc_hd__decap_3
XFILLER_95_438 VGND VGND VPWR VPWR sky130_fd_sc_hd__decap_3
XFILLER_48_321 VGND VGND VPWR VPWR sky130_fd_sc_hd__decap_3
XFILLER_48_376 VGND VGND VPWR VPWR sky130_fd_sc_hd__decap_3
XFILLER_63_302 VGND VGND VPWR VPWR sky130_fd_sc_hd__decap_3
XFILLER_75_151 VGND VGND VPWR VPWR sky130_fd_sc_hd__decap_3
XFILLER_63_335 VGND VGND VPWR VPWR sky130_fd_sc_hd__fill_1
XFILLER_63_346 VGND VGND VPWR VPWR sky130_fd_sc_hd__decap_3
XFILLER_75_184 VGND VGND VPWR VPWR sky130_fd_sc_hd__decap_3
XFILLER_90_121 VGND VGND VPWR VPWR sky130_fd_sc_hd__fill_1
Xplace313 _4583_/B VGND VGND VPWR VPWR _4569_/B sky130_fd_sc_hd__buf_2
Xplace302 _3640_/X VGND VGND VPWR VPWR _3665_/B sky130_fd_sc_hd__buf_2
XFILLER_16_251 VGND VGND VPWR VPWR sky130_fd_sc_hd__fill_1
XFILLER_63_379 VGND VGND VPWR VPWR sky130_fd_sc_hd__decap_3
Xplace346 _3618_/C VGND VGND VPWR VPWR _4764_/B sky130_fd_sc_hd__buf_2
Xplace335 _3591_/A VGND VGND VPWR VPWR _4376_/A sky130_fd_sc_hd__buf_2
Xplace324 _3358_/X VGND VGND VPWR VPWR _4601_/S sky130_fd_sc_hd__buf_2
XFILLER_16_262 VGND VGND VPWR VPWR sky130_fd_sc_hd__decap_3
XFILLER_90_187 VGND VGND VPWR VPWR sky130_fd_sc_hd__fill_1
Xplace379 _4466_/A VGND VGND VPWR VPWR _3753_/B1 sky130_fd_sc_hd__buf_2
Xplace368 _3556_/A VGND VGND VPWR VPWR _4248_/A sky130_fd_sc_hd__buf_2
Xplace357 _4417_/A2 VGND VGND VPWR VPWR _4879_/S sky130_fd_sc_hd__buf_2
XFILLER_16_295 VGND VGND VPWR VPWR sky130_fd_sc_hd__decap_3
X_3870_ _6760_/Q _3882_/A2 _3913_/B1 _6754_/Q _3869_/X VGND VGND VPWR VPWR _3870_/X
+ sky130_fd_sc_hd__a221o_2
XFILLER_31_254 VGND VGND VPWR VPWR sky130_fd_sc_hd__fill_2
XFILLER_31_265 VGND VGND VPWR VPWR sky130_fd_sc_hd__decap_3
XTAP_TAPCELL_ROW_42_761 VGND VPWR sky130_fd_sc_hd__tapvpwrvgnd_1
XTAP_TAPCELL_ROW_42_750 VGND VPWR sky130_fd_sc_hd__tapvpwrvgnd_1
XFILLER_31_287 VGND VGND VPWR VPWR sky130_fd_sc_hd__fill_2
XFILLER_76_3 VGND VGND VPWR VPWR sky130_fd_sc_hd__decap_3
Xclkbuf_leaf_11_clk clkbuf_leaf_7_clk/A VGND VGND VPWR VPWR _7365_/CLK sky130_fd_sc_hd__clkbuf_16
X_7210_ _7362_/CLK _7210_/D _6490_/Y VGND VGND VPWR VPWR _7210_/Q sky130_fd_sc_hd__dfrtp_2
X_4422_ _7272_/Q _4422_/A2 _4419_/X _4421_/X VGND VGND VPWR VPWR _4422_/X sky130_fd_sc_hd__a211o_2
XTAP_TAPCELL_ROW_113_1613 VGND VPWR sky130_fd_sc_hd__tapvpwrvgnd_1
XTAP_TAPCELL_ROW_113_1602 VGND VPWR sky130_fd_sc_hd__tapvpwrvgnd_1
X_7141_ _7365_/CLK _7141_/D _6421_/Y VGND VGND VPWR VPWR _7141_/Q sky130_fd_sc_hd__dfrtp_2
X_4353_ _7225_/Q _4469_/A3 _3968_/S _7193_/Q VGND VGND VPWR VPWR _4355_/A sky130_fd_sc_hd__a22o_2
X_7072_ _7364_/CLK _7072_/D _6352_/Y VGND VGND VPWR VPWR _7072_/Q sky130_fd_sc_hd__dfrtp_2
X_4284_ _7222_/Q _4307_/A2 _3977_/S _7190_/Q VGND VGND VPWR VPWR _4286_/A sky130_fd_sc_hd__a22o_2
X_3304_ _6982_/Q _3353_/A VGND VGND VPWR VPWR _4696_/B sky130_fd_sc_hd__nand2_2
XFILLER_98_265 VGND VGND VPWR VPWR sky130_fd_sc_hd__decap_3
XFILLER_86_416 VGND VGND VPWR VPWR sky130_fd_sc_hd__fill_1
XFILLER_86_427 VGND VGND VPWR VPWR sky130_fd_sc_hd__decap_3
XFILLER_100_237 VGND VGND VPWR VPWR sky130_fd_sc_hd__decap_3
XFILLER_100_259 VGND VGND VPWR VPWR sky130_fd_sc_hd__decap_3
XFILLER_104_27 VGND VGND VPWR VPWR sky130_fd_sc_hd__fill_1
XFILLER_39_343 VGND VGND VPWR VPWR sky130_fd_sc_hd__fill_2
XFILLER_104_38 VGND VGND VPWR VPWR sky130_fd_sc_hd__decap_3
XFILLER_27_505 VGND VGND VPWR VPWR sky130_fd_sc_hd__decap_3
XFILLER_39_354 VGND VGND VPWR VPWR sky130_fd_sc_hd__decap_3
XFILLER_54_302 VGND VGND VPWR VPWR sky130_fd_sc_hd__decap_3
XFILLER_66_162 VGND VGND VPWR VPWR sky130_fd_sc_hd__decap_3
XFILLER_39_387 VGND VGND VPWR VPWR sky130_fd_sc_hd__decap_3
XFILLER_54_335 VGND VGND VPWR VPWR sky130_fd_sc_hd__decap_3
XFILLER_81_110 VGND VGND VPWR VPWR sky130_fd_sc_hd__fill_2
XFILLER_82_655 VGND VGND VPWR VPWR sky130_fd_sc_hd__decap_3
XFILLER_54_368 VGND VGND VPWR VPWR sky130_fd_sc_hd__fill_1
XFILLER_54_379 VGND VGND VPWR VPWR sky130_fd_sc_hd__decap_3
XFILLER_82_688 VGND VGND VPWR VPWR sky130_fd_sc_hd__decap_3
X_6925_ clkload1/A _6925_/D VGND VGND VPWR VPWR _6925_/Q sky130_fd_sc_hd__dfxtp_2
XFILLER_81_187 VGND VGND VPWR VPWR sky130_fd_sc_hd__decap_3
XFILLER_22_221 VGND VGND VPWR VPWR sky130_fd_sc_hd__decap_3
XFILLER_50_541 VGND VGND VPWR VPWR sky130_fd_sc_hd__decap_3
Xfanout25 _6664_/A VGND VGND VPWR VPWR _6635_/A sky130_fd_sc_hd__buf_2
Xfanout36 _6644_/A VGND VGND VPWR VPWR _6608_/A sky130_fd_sc_hd__buf_2
Xfanout47 wire582/X VGND VGND VPWR VPWR _6643_/A sky130_fd_sc_hd__clkdlybuf4s25_1
X_6856_ _6965_/CLK _6856_/D VGND VGND VPWR VPWR _6856_/Q sky130_fd_sc_hd__dfxtp_2
XFILLER_10_416 VGND VGND VPWR VPWR sky130_fd_sc_hd__decap_3
XFILLER_22_265 VGND VGND VPWR VPWR sky130_fd_sc_hd__decap_3
Xfanout58 reset VGND VGND VPWR VPWR _6288_/A sky130_fd_sc_hd__buf_1
Xfanout69 _6523_/A VGND VGND VPWR VPWR _6553_/A sky130_fd_sc_hd__buf_2
X_6787_ _7383_/CLK _6787_/D VGND VGND VPWR VPWR _6787_/Q sky130_fd_sc_hd__dfxtp_2
XFILLER_10_427 VGND VGND VPWR VPWR sky130_fd_sc_hd__fill_2
XFILLER_10_438 VGND VGND VPWR VPWR sky130_fd_sc_hd__decap_3
XFILLER_13_35 VGND VGND VPWR VPWR sky130_fd_sc_hd__decap_3
XFILLER_13_57 VGND VGND VPWR VPWR sky130_fd_sc_hd__decap_3
XFILLER_22_287 VGND VGND VPWR VPWR sky130_fd_sc_hd__decap_3
XFILLER_108_315 VGND VGND VPWR VPWR sky130_fd_sc_hd__decap_3
XFILLER_13_79 VGND VGND VPWR VPWR sky130_fd_sc_hd__decap_3
XTAP_TAPCELL_ROW_20_488 VGND VPWR sky130_fd_sc_hd__tapvpwrvgnd_1
XFILLER_89_221 VGND VGND VPWR VPWR sky130_fd_sc_hd__decap_3
X_7339_ _7371_/CLK _7339_/D _6619_/Y VGND VGND VPWR VPWR _7339_/Q sky130_fd_sc_hd__dfrtp_2
XFILLER_77_405 VGND VGND VPWR VPWR sky130_fd_sc_hd__decap_3
XFILLER_89_243 VGND VGND VPWR VPWR sky130_fd_sc_hd__decap_3
XPHY_EDGE_ROW_8_Left_125 VGND VGND VPWR VPWR sky130_fd_sc_hd__decap_3
XFILLER_38_21 VGND VGND VPWR VPWR sky130_fd_sc_hd__fill_2
XFILLER_77_438 VGND VGND VPWR VPWR sky130_fd_sc_hd__decap_3
XFILLER_38_32 VGND VGND VPWR VPWR sky130_fd_sc_hd__decap_3
XFILLER_38_54 VGND VGND VPWR VPWR sky130_fd_sc_hd__decap_3
XFILLER_77_449 VGND VGND VPWR VPWR sky130_fd_sc_hd__fill_2
XFILLER_45_302 VGND VGND VPWR VPWR sky130_fd_sc_hd__decap_3
XFILLER_57_140 VGND VGND VPWR VPWR sky130_fd_sc_hd__fill_2
XFILLER_57_162 VGND VGND VPWR VPWR sky130_fd_sc_hd__decap_3
XFILLER_58_674 VGND VGND VPWR VPWR sky130_fd_sc_hd__fill_1
XFILLER_92_419 VGND VGND VPWR VPWR sky130_fd_sc_hd__fill_1
Xhold1150 _7176_/Q VGND VGND VPWR VPWR _5308_/A0 sky130_fd_sc_hd__dlygate4sd3_1
XFILLER_45_313 VGND VGND VPWR VPWR sky130_fd_sc_hd__decap_3
XFILLER_57_195 VGND VGND VPWR VPWR sky130_fd_sc_hd__decap_3
Xhold1161 _7051_/Q VGND VGND VPWR VPWR _5566_/A1 sky130_fd_sc_hd__dlygate4sd3_1
Xhold1172 _7151_/Q VGND VGND VPWR VPWR _5360_/A0 sky130_fd_sc_hd__dlygate4sd3_1
Xhold1183 _7160_/Q VGND VGND VPWR VPWR _5342_/A0 sky130_fd_sc_hd__dlygate4sd3_1
Xhold1194 _7144_/Q VGND VGND VPWR VPWR _5377_/A0 sky130_fd_sc_hd__dlygate4sd3_1
XFILLER_45_346 VGND VGND VPWR VPWR sky130_fd_sc_hd__decap_3
XFILLER_26_560 VGND VGND VPWR VPWR sky130_fd_sc_hd__decap_3
XFILLER_26_571 VGND VGND VPWR VPWR sky130_fd_sc_hd__decap_3
XFILLER_54_53 VGND VGND VPWR VPWR sky130_fd_sc_hd__decap_3
XTAP_TAPCELL_ROW_28_588 VGND VPWR sky130_fd_sc_hd__tapvpwrvgnd_1
XFILLER_13_243 VGND VGND VPWR VPWR sky130_fd_sc_hd__decap_3
XFILLER_26_593 VGND VGND VPWR VPWR sky130_fd_sc_hd__fill_1
XFILLER_41_541 VGND VGND VPWR VPWR sky130_fd_sc_hd__fill_1
XFILLER_60_349 VGND VGND VPWR VPWR sky130_fd_sc_hd__decap_3
XFILLER_110_70 VGND VGND VPWR VPWR sky130_fd_sc_hd__decap_3
XFILLER_13_265 VGND VGND VPWR VPWR sky130_fd_sc_hd__decap_3
XFILLER_9_225 VGND VGND VPWR VPWR sky130_fd_sc_hd__decap_3
XFILLER_9_214 VGND VGND VPWR VPWR sky130_fd_sc_hd__decap_3
XFILLER_13_287 VGND VGND VPWR VPWR sky130_fd_sc_hd__fill_1
XFILLER_70_41 VGND VGND VPWR VPWR sky130_fd_sc_hd__decap_3
XFILLER_9_258 VGND VGND VPWR VPWR sky130_fd_sc_hd__decap_3
XFILLER_70_63 VGND VGND VPWR VPWR sky130_fd_sc_hd__decap_3
XFILLER_70_85 VGND VGND VPWR VPWR sky130_fd_sc_hd__decap_3
XFILLER_70_96 VGND VGND VPWR VPWR sky130_fd_sc_hd__decap_3
Xclkload17 _6965_/CLK VGND VGND VPWR VPWR clkload17/X sky130_fd_sc_hd__clkbuf_1
XFILLER_5_420 VGND VGND VPWR VPWR sky130_fd_sc_hd__decap_3
Xclkload28 _7393_/CLK VGND VGND VPWR VPWR clkload28/Y sky130_fd_sc_hd__clkinv_2
XFILLER_114_318 VGND VGND VPWR VPWR sky130_fd_sc_hd__fill_1
XFILLER_107_370 VGND VGND VPWR VPWR sky130_fd_sc_hd__decap_3
XFILLER_68_416 VGND VGND VPWR VPWR sky130_fd_sc_hd__decap_3
XFILLER_68_427 VGND VGND VPWR VPWR sky130_fd_sc_hd__fill_2
XFILLER_95_202 VGND VGND VPWR VPWR sky130_fd_sc_hd__decap_3
XFILLER_110_557 VGND VGND VPWR VPWR sky130_fd_sc_hd__decap_3
XFILLER_95_246 VGND VGND VPWR VPWR sky130_fd_sc_hd__decap_3
XFILLER_76_460 VGND VGND VPWR VPWR sky130_fd_sc_hd__decap_3
XFILLER_95_279 VGND VGND VPWR VPWR sky130_fd_sc_hd__fill_1
XFILLER_95_60 VGND VGND VPWR VPWR sky130_fd_sc_hd__decap_3
Xclkbuf_leaf_0_clk clkbuf_leaf_1_clk/A VGND VGND VPWR VPWR _7258_/CLK sky130_fd_sc_hd__clkbuf_16
XFILLER_36_324 VGND VGND VPWR VPWR sky130_fd_sc_hd__decap_3
XFILLER_48_195 VGND VGND VPWR VPWR sky130_fd_sc_hd__fill_1
XFILLER_63_110 VGND VGND VPWR VPWR sky130_fd_sc_hd__fill_2
XFILLER_64_622 VGND VGND VPWR VPWR sky130_fd_sc_hd__fill_2
XTAP_TAPCELL_ROW_47_820 VGND VPWR sky130_fd_sc_hd__tapvpwrvgnd_1
XFILLER_91_452 VGND VGND VPWR VPWR sky130_fd_sc_hd__decap_3
XFILLER_51_305 VGND VGND VPWR VPWR sky130_fd_sc_hd__decap_3
X_4971_ _5103_/A1 _4949_/Y _4967_/X _4969_/X _4970_/X VGND VGND VPWR VPWR _5661_/B
+ sky130_fd_sc_hd__a311oi_2
XFILLER_51_349 VGND VGND VPWR VPWR sky130_fd_sc_hd__fill_1
X_6710_ _6966_/CLK _6710_/D VGND VGND VPWR VPWR _6710_/Q sky130_fd_sc_hd__dfxtp_2
X_3922_ _6778_/Q _3922_/A2 _3925_/B1 _6866_/Q _3921_/X VGND VGND VPWR VPWR _3922_/X
+ sky130_fd_sc_hd__a221o_2
XTAP_TAPCELL_ROW_63_1011 VGND VPWR sky130_fd_sc_hd__tapvpwrvgnd_1
X_6641_ _6674_/A VGND VGND VPWR VPWR _6641_/Y sky130_fd_sc_hd__inv_2
X_3853_ _6736_/Q _3853_/A2 _5660_/B _6730_/Q _3852_/X VGND VGND VPWR VPWR _3853_/X
+ sky130_fd_sc_hd__a221o_2
X_6572_ _6604_/A VGND VGND VPWR VPWR _6572_/Y sky130_fd_sc_hd__inv_2
X_3784_ _6847_/Q _3661_/X _3852_/B1 _6842_/Q VGND VGND VPWR VPWR _3784_/X sky130_fd_sc_hd__a22o_2
XFILLER_105_318 VGND VGND VPWR VPWR sky130_fd_sc_hd__decap_3
Xoutput511 _3562_/B VGND VGND VPWR VPWR instruction_out[25] sky130_fd_sc_hd__clkdlybuf4s25_1
Xoutput500 _3525_/A VGND VGND VPWR VPWR instruction_out[13] sky130_fd_sc_hd__clkdlybuf4s25_1
Xoutput544 _7005_/Q VGND VGND VPWR VPWR pc_out[28] sky130_fd_sc_hd__clkdlybuf4s25_1
Xoutput533 _6995_/Q VGND VGND VPWR VPWR pc_out[18] sky130_fd_sc_hd__clkdlybuf4s25_1
Xoutput522 _5362_/C VGND VGND VPWR VPWR instruction_out[8] sky130_fd_sc_hd__clkdlybuf4s25_1
X_4405_ _7242_/Q _4433_/B _3947_/S _7210_/Q VGND VGND VPWR VPWR _4405_/X sky130_fd_sc_hd__a22o_2
XFILLER_113_340 VGND VGND VPWR VPWR sky130_fd_sc_hd__decap_3
X_7124_ clkload5/A _7124_/D _6404_/Y VGND VGND VPWR VPWR _7124_/Q sky130_fd_sc_hd__dfrtp_2
Xoutput555 _6986_/Q VGND VGND VPWR VPWR pc_out[9] sky130_fd_sc_hd__clkdlybuf4s25_1
X_4336_ _4336_/A _4336_/B _4336_/C VGND VGND VPWR VPWR _4336_/X sky130_fd_sc_hd__or3_2
XTAP_TAPCELL_ROW_74_1140 VGND VPWR sky130_fd_sc_hd__tapvpwrvgnd_1
XFILLER_99_552 VGND VGND VPWR VPWR sky130_fd_sc_hd__decap_3
XFILLER_113_373 VGND VGND VPWR VPWR sky130_fd_sc_hd__decap_3
XFILLER_59_405 VGND VGND VPWR VPWR sky130_fd_sc_hd__decap_3
XFILLER_59_438 VGND VGND VPWR VPWR sky130_fd_sc_hd__decap_3
XFILLER_59_449 VGND VGND VPWR VPWR sky130_fd_sc_hd__decap_3
XFILLER_86_224 VGND VGND VPWR VPWR sky130_fd_sc_hd__decap_3
X_7055_ clkload9/A _7055_/D _6335_/Y VGND VGND VPWR VPWR _7055_/Q sky130_fd_sc_hd__dfrtp_2
X_4267_ _7134_/Q _4351_/B1 _4267_/B1 _7166_/Q VGND VGND VPWR VPWR _4271_/B sky130_fd_sc_hd__a22o_2
XFILLER_27_302 VGND VGND VPWR VPWR sky130_fd_sc_hd__decap_3
XFILLER_39_151 VGND VGND VPWR VPWR sky130_fd_sc_hd__decap_3
XFILLER_55_611 VGND VGND VPWR VPWR sky130_fd_sc_hd__decap_3
XFILLER_86_279 VGND VGND VPWR VPWR sky130_fd_sc_hd__decap_3
X_4198_ _4194_/X _4197_/X _4327_/A VGND VGND VPWR VPWR _4380_/B sky130_fd_sc_hd__o21ai_2
XFILLER_54_121 VGND VGND VPWR VPWR sky130_fd_sc_hd__decap_3
XFILLER_67_493 VGND VGND VPWR VPWR sky130_fd_sc_hd__decap_3
XFILLER_82_430 VGND VGND VPWR VPWR sky130_fd_sc_hd__decap_3
XFILLER_27_346 VGND VGND VPWR VPWR sky130_fd_sc_hd__decap_3
XFILLER_82_463 VGND VGND VPWR VPWR sky130_fd_sc_hd__decap_3
XFILLER_94_290 VGND VGND VPWR VPWR sky130_fd_sc_hd__decap_3
XFILLER_27_379 VGND VGND VPWR VPWR sky130_fd_sc_hd__decap_3
XFILLER_42_305 VGND VGND VPWR VPWR sky130_fd_sc_hd__decap_3
XFILLER_23_541 VGND VGND VPWR VPWR sky130_fd_sc_hd__fill_2
XFILLER_24_23 VGND VGND VPWR VPWR sky130_fd_sc_hd__decap_3
XFILLER_70_669 VGND VGND VPWR VPWR sky130_fd_sc_hd__fill_2
X_6908_ _6965_/CLK _6908_/D VGND VGND VPWR VPWR _6908_/Q sky130_fd_sc_hd__dfxtp_2
XTAP_TAPCELL_ROW_25_547 VGND VPWR sky130_fd_sc_hd__tapvpwrvgnd_1
XFILLER_24_56 VGND VGND VPWR VPWR sky130_fd_sc_hd__decap_3
XFILLER_50_360 VGND VGND VPWR VPWR sky130_fd_sc_hd__decap_3
X_6839_ _6972_/CLK _6839_/D VGND VGND VPWR VPWR _6839_/Q sky130_fd_sc_hd__dfxtp_2
XTAP_TAPCELL_ROW_53_889 VGND VPWR sky130_fd_sc_hd__tapvpwrvgnd_1
XFILLER_24_78 VGND VGND VPWR VPWR sky130_fd_sc_hd__decap_3
XFILLER_50_393 VGND VGND VPWR VPWR sky130_fd_sc_hd__decap_3
XFILLER_6_206 VGND VGND VPWR VPWR sky130_fd_sc_hd__decap_3
XFILLER_108_112 VGND VGND VPWR VPWR sky130_fd_sc_hd__fill_1
XFILLER_109_646 VGND VGND VPWR VPWR sky130_fd_sc_hd__decap_3
XFILLER_40_44 VGND VGND VPWR VPWR sky130_fd_sc_hd__decap_3
XFILLER_6_239 VGND VGND VPWR VPWR sky130_fd_sc_hd__decap_3
XFILLER_108_167 VGND VGND VPWR VPWR sky130_fd_sc_hd__decap_3
XFILLER_109_679 VGND VGND VPWR VPWR sky130_fd_sc_hd__fill_2
XFILLER_6_3 VGND VGND VPWR VPWR sky130_fd_sc_hd__decap_3
XFILLER_104_351 VGND VGND VPWR VPWR sky130_fd_sc_hd__decap_3
XFILLER_104_373 VGND VGND VPWR VPWR sky130_fd_sc_hd__decap_3
XFILLER_77_246 VGND VGND VPWR VPWR sky130_fd_sc_hd__decap_3
XFILLER_58_460 VGND VGND VPWR VPWR sky130_fd_sc_hd__decap_3
XFILLER_65_408 VGND VGND VPWR VPWR sky130_fd_sc_hd__decap_3
XTAP_TAPCELL_ROW_88_1309 VGND VPWR sky130_fd_sc_hd__tapvpwrvgnd_1
XFILLER_105_81 VGND VGND VPWR VPWR sky130_fd_sc_hd__decap_3
XFILLER_45_110 VGND VGND VPWR VPWR sky130_fd_sc_hd__fill_2
XFILLER_65_41 VGND VGND VPWR VPWR sky130_fd_sc_hd__decap_3
XFILLER_92_238 VGND VGND VPWR VPWR sky130_fd_sc_hd__decap_3
XFILLER_45_143 VGND VGND VPWR VPWR sky130_fd_sc_hd__decap_3
XFILLER_65_63 VGND VGND VPWR VPWR sky130_fd_sc_hd__decap_3
XFILLER_73_463 VGND VGND VPWR VPWR sky130_fd_sc_hd__decap_3
XFILLER_73_496 VGND VGND VPWR VPWR sky130_fd_sc_hd__decap_3
XFILLER_33_349 VGND VGND VPWR VPWR sky130_fd_sc_hd__decap_3
XFILLER_41_360 VGND VGND VPWR VPWR sky130_fd_sc_hd__decap_3
XFILLER_60_179 VGND VGND VPWR VPWR sky130_fd_sc_hd__decap_3
XFILLER_81_84 VGND VGND VPWR VPWR sky130_fd_sc_hd__fill_2
XTAP_TAPCELL_ROW_99_1438 VGND VPWR sky130_fd_sc_hd__tapvpwrvgnd_1
XFILLER_60_6 VGND VGND VPWR VPWR sky130_fd_sc_hd__fill_2
XFILLER_114_104 VGND VGND VPWR VPWR sky130_fd_sc_hd__decap_3
XFILLER_39_3 VGND VGND VPWR VPWR sky130_fd_sc_hd__decap_3
XFILLER_96_522 VGND VGND VPWR VPWR sky130_fd_sc_hd__fill_1
XFILLER_68_224 VGND VGND VPWR VPWR sky130_fd_sc_hd__decap_3
XFILLER_68_246 VGND VGND VPWR VPWR sky130_fd_sc_hd__decap_3
XFILLER_96_533 VGND VGND VPWR VPWR sky130_fd_sc_hd__decap_3
X_4121_ _7140_/Q _4195_/A2 _4267_/B1 _7172_/Q _4120_/X VGND VGND VPWR VPWR _4121_/X
+ sky130_fd_sc_hd__a221o_2
XFILLER_68_279 VGND VGND VPWR VPWR sky130_fd_sc_hd__decap_3
XFILLER_96_566 VGND VGND VPWR VPWR sky130_fd_sc_hd__decap_3
X_4052_ _4047_/X _4050_/X _4425_/A VGND VGND VPWR VPWR _4456_/A sky130_fd_sc_hd__o21a_2
XFILLER_110_398 VGND VGND VPWR VPWR sky130_fd_sc_hd__decap_3
XFILLER_83_249 VGND VGND VPWR VPWR sky130_fd_sc_hd__decap_3
XFILLER_96_599 VGND VGND VPWR VPWR sky130_fd_sc_hd__fill_2
XFILLER_36_132 VGND VGND VPWR VPWR sky130_fd_sc_hd__decap_3
XTAP_TAPCELL_ROW_108_1545 VGND VPWR sky130_fd_sc_hd__tapvpwrvgnd_1
XFILLER_36_176 VGND VGND VPWR VPWR sky130_fd_sc_hd__decap_3
XFILLER_52_614 VGND VGND VPWR VPWR sky130_fd_sc_hd__fill_1
XFILLER_64_474 VGND VGND VPWR VPWR sky130_fd_sc_hd__fill_2
XFILLER_101_17 VGND VGND VPWR VPWR sky130_fd_sc_hd__decap_3
XFILLER_51_113 VGND VGND VPWR VPWR sky130_fd_sc_hd__decap_3
X_4954_ _4186_/Y _4969_/C _4953_/Y _4200_/X VGND VGND VPWR VPWR _4954_/X sky130_fd_sc_hd__o211a_2
XFILLER_51_157 VGND VGND VPWR VPWR sky130_fd_sc_hd__decap_3
XFILLER_51_179 VGND VGND VPWR VPWR sky130_fd_sc_hd__decap_3
X_3905_ hold961/X _5104_/A _3904_/Y VGND VGND VPWR VPWR _7380_/D sky130_fd_sc_hd__a21bo_2
XFILLER_60_691 VGND VGND VPWR VPWR sky130_fd_sc_hd__fill_1
X_4885_ _4904_/B _4903_/A VGND VGND VPWR VPWR _4886_/C sky130_fd_sc_hd__and2b_2
XTAP_TAPCELL_ROW_50_848 VGND VPWR sky130_fd_sc_hd__tapvpwrvgnd_1
XTAP_TAPCELL_ROW_22_517 VGND VPWR sky130_fd_sc_hd__tapvpwrvgnd_1
X_6624_ _6660_/A VGND VGND VPWR VPWR _6624_/Y sky130_fd_sc_hd__inv_2
X_3836_ _6970_/Q _5660_/B _3852_/B1 _6720_/Q _3835_/X VGND VGND VPWR VPWR _3836_/X
+ sky130_fd_sc_hd__a221o_2
X_6555_ _6647_/A VGND VGND VPWR VPWR _6555_/Y sky130_fd_sc_hd__inv_2
X_3767_ _6705_/Q _3863_/A2 _3858_/B1 _6883_/Q VGND VGND VPWR VPWR _3767_/X sky130_fd_sc_hd__a22o_2
XPHY_EDGE_ROW_89_Left_206 VGND VGND VPWR VPWR sky130_fd_sc_hd__decap_3
XFILLER_10_25 VGND VGND VPWR VPWR sky130_fd_sc_hd__decap_3
X_6486_ _6684_/A VGND VGND VPWR VPWR _6486_/Y sky130_fd_sc_hd__inv_2
X_3698_ _3698_/A1 _4832_/A _3697_/Y VGND VGND VPWR VPWR _7402_/D sky130_fd_sc_hd__o21ba_2
XFILLER_10_69 VGND VGND VPWR VPWR sky130_fd_sc_hd__decap_3
XFILLER_86_29 VGND VGND VPWR VPWR sky130_fd_sc_hd__decap_3
XFILLER_87_500 VGND VGND VPWR VPWR sky130_fd_sc_hd__decap_3
XFILLER_113_192 VGND VGND VPWR VPWR sky130_fd_sc_hd__decap_3
XFILLER_59_246 VGND VGND VPWR VPWR sky130_fd_sc_hd__decap_3
X_7107_ _7363_/CLK _7107_/D _6387_/Y VGND VGND VPWR VPWR _7107_/Q sky130_fd_sc_hd__dfrtp_2
X_4319_ _7258_/Q _3358_/X _4316_/X _4318_/X VGND VGND VPWR VPWR _4362_/A sky130_fd_sc_hd__a211o_2
XFILLER_99_382 VGND VGND VPWR VPWR sky130_fd_sc_hd__decap_3
XFILLER_101_354 VGND VGND VPWR VPWR sky130_fd_sc_hd__decap_3
XFILLER_19_23 VGND VGND VPWR VPWR sky130_fd_sc_hd__decap_3
XFILLER_47_408 VGND VGND VPWR VPWR sky130_fd_sc_hd__decap_3
XFILLER_87_588 VGND VGND VPWR VPWR sky130_fd_sc_hd__fill_1
X_7038_ _7394_/CLK _7038_/D _6318_/Y VGND VGND VPWR VPWR _7038_/Q sky130_fd_sc_hd__dfrtp_2
XPHY_EDGE_ROW_98_Left_215 VGND VGND VPWR VPWR sky130_fd_sc_hd__decap_3
XFILLER_101_387 VGND VGND VPWR VPWR sky130_fd_sc_hd__decap_3
XTAP_TAPCELL_ROW_58_948 VGND VPWR sky130_fd_sc_hd__tapvpwrvgnd_1
XFILLER_27_143 VGND VGND VPWR VPWR sky130_fd_sc_hd__decap_3
XFILLER_55_430 VGND VGND VPWR VPWR sky130_fd_sc_hd__decap_3
XFILLER_55_452 VGND VGND VPWR VPWR sky130_fd_sc_hd__decap_3
XFILLER_67_290 VGND VGND VPWR VPWR sky130_fd_sc_hd__decap_3
XFILLER_15_316 VGND VGND VPWR VPWR sky130_fd_sc_hd__decap_3
XFILLER_35_33 VGND VGND VPWR VPWR sky130_fd_sc_hd__decap_3
XFILLER_70_400 VGND VGND VPWR VPWR sky130_fd_sc_hd__decap_3
XTAP_TAPCELL_ROW_2_275 VGND VPWR sky130_fd_sc_hd__tapvpwrvgnd_1
XFILLER_15_349 VGND VGND VPWR VPWR sky130_fd_sc_hd__decap_3
XFILLER_27_187 VGND VGND VPWR VPWR sky130_fd_sc_hd__fill_1
XFILLER_42_124 VGND VGND VPWR VPWR sky130_fd_sc_hd__decap_3
XFILLER_43_669 VGND VGND VPWR VPWR sky130_fd_sc_hd__decap_3
XFILLER_55_496 VGND VGND VPWR VPWR sky130_fd_sc_hd__decap_3
XFILLER_70_444 VGND VGND VPWR VPWR sky130_fd_sc_hd__decap_3
XFILLER_35_99 VGND VGND VPWR VPWR sky130_fd_sc_hd__decap_3
XFILLER_70_477 VGND VGND VPWR VPWR sky130_fd_sc_hd__decap_3
XFILLER_23_360 VGND VGND VPWR VPWR sky130_fd_sc_hd__decap_3
XFILLER_23_393 VGND VGND VPWR VPWR sky130_fd_sc_hd__decap_3
XFILLER_51_21 VGND VGND VPWR VPWR sky130_fd_sc_hd__fill_1
XFILLER_51_43 VGND VGND VPWR VPWR sky130_fd_sc_hd__fill_2
XFILLER_51_87 VGND VGND VPWR VPWR sky130_fd_sc_hd__fill_1
XFILLER_7_548 VGND VGND VPWR VPWR sky130_fd_sc_hd__fill_1
XFILLER_109_443 VGND VGND VPWR VPWR sky130_fd_sc_hd__decap_3
XFILLER_51_98 VGND VGND VPWR VPWR sky130_fd_sc_hd__decap_3
XTAP_TAPCELL_ROW_94_1379 VGND VPWR sky130_fd_sc_hd__tapvpwrvgnd_1
XFILLER_2_253 VGND VGND VPWR VPWR sky130_fd_sc_hd__fill_2
XFILLER_78_511 VGND VGND VPWR VPWR sky130_fd_sc_hd__fill_1
XFILLER_97_308 VGND VGND VPWR VPWR sky130_fd_sc_hd__fill_1
XFILLER_104_192 VGND VGND VPWR VPWR sky130_fd_sc_hd__decap_3
XFILLER_78_533 VGND VGND VPWR VPWR sky130_fd_sc_hd__fill_2
XFILLER_116_80 VGND VGND VPWR VPWR sky130_fd_sc_hd__decap_3
XFILLER_25_9 VGND VGND VPWR VPWR sky130_fd_sc_hd__decap_3
XFILLER_65_205 VGND VGND VPWR VPWR sky130_fd_sc_hd__decap_3
XFILLER_76_62 VGND VGND VPWR VPWR sky130_fd_sc_hd__decap_3
XFILLER_80_219 VGND VGND VPWR VPWR sky130_fd_sc_hd__decap_3
XFILLER_18_187 VGND VGND VPWR VPWR sky130_fd_sc_hd__decap_3
XFILLER_33_113 VGND VGND VPWR VPWR sky130_fd_sc_hd__decap_3
XFILLER_33_135 VGND VGND VPWR VPWR sky130_fd_sc_hd__decap_3
XFILLER_92_61 VGND VGND VPWR VPWR sky130_fd_sc_hd__decap_3
XFILLER_21_319 VGND VGND VPWR VPWR sky130_fd_sc_hd__decap_3
XFILLER_61_455 VGND VGND VPWR VPWR sky130_fd_sc_hd__decap_3
XFILLER_92_94 VGND VGND VPWR VPWR sky130_fd_sc_hd__decap_3
XFILLER_61_499 VGND VGND VPWR VPWR sky130_fd_sc_hd__decap_3
XTAP_TAPCELL_ROW_103_1486 VGND VPWR sky130_fd_sc_hd__tapvpwrvgnd_1
X_4670_ _6995_/Q _5605_/B VGND VGND VPWR VPWR _4682_/B sky130_fd_sc_hd__or2_2
X_3621_ _3621_/A _3621_/B VGND VGND VPWR VPWR _4852_/A sky130_fd_sc_hd__nand2_2
X_6340_ _6347_/A VGND VGND VPWR VPWR _6340_/Y sky130_fd_sc_hd__inv_2
X_3552_ _3508_/Y _5020_/A _3620_/A _3537_/X _3551_/X VGND VGND VPWR VPWR _3746_/A
+ sky130_fd_sc_hd__o311a_2
XFILLER_115_446 VGND VGND VPWR VPWR sky130_fd_sc_hd__fill_2
X_6271_ _6553_/A VGND VGND VPWR VPWR _6271_/Y sky130_fd_sc_hd__inv_2
X_3483_ _3442_/A _3442_/B _3409_/D VGND VGND VPWR VPWR _5153_/B sky130_fd_sc_hd__a21o_2
XFILLER_102_118 VGND VGND VPWR VPWR sky130_fd_sc_hd__decap_3
XFILLER_69_511 VGND VGND VPWR VPWR sky130_fd_sc_hd__decap_3
XFILLER_96_330 VGND VGND VPWR VPWR sky130_fd_sc_hd__decap_3
X_5153_ _7010_/D _5153_/B VGND VGND VPWR VPWR _5153_/X sky130_fd_sc_hd__xor2_2
XFILLER_69_577 VGND VGND VPWR VPWR sky130_fd_sc_hd__fill_1
XFILLER_96_363 VGND VGND VPWR VPWR sky130_fd_sc_hd__fill_1
X_4104_ _7237_/Q _4414_/A2 _4505_/S _7050_/Q VGND VGND VPWR VPWR _4104_/X sky130_fd_sc_hd__a22o_2
XFILLER_56_227 VGND VGND VPWR VPWR sky130_fd_sc_hd__decap_3
XFILLER_84_525 VGND VGND VPWR VPWR sky130_fd_sc_hd__decap_3
XFILLER_84_536 VGND VGND VPWR VPWR sky130_fd_sc_hd__decap_3
XFILLER_96_374 VGND VGND VPWR VPWR sky130_fd_sc_hd__decap_3
X_5084_ _4343_/X _5084_/B _5086_/A VGND VGND VPWR VPWR _5084_/X sky130_fd_sc_hd__and3b_2
XFILLER_37_452 VGND VGND VPWR VPWR sky130_fd_sc_hd__decap_3
XFILLER_49_290 VGND VGND VPWR VPWR sky130_fd_sc_hd__decap_3
X_4035_ _7374_/Q _4435_/B1 _4436_/B1 _7182_/Q _4034_/X VGND VGND VPWR VPWR _4035_/X
+ sky130_fd_sc_hd__a221o_2
XTAP_TAPCELL_ROW_55_907 VGND VPWR sky130_fd_sc_hd__tapvpwrvgnd_1
XFILLER_112_27 VGND VGND VPWR VPWR sky130_fd_sc_hd__fill_1
XFILLER_52_411 VGND VGND VPWR VPWR sky130_fd_sc_hd__decap_3
XFILLER_71_208 VGND VGND VPWR VPWR sky130_fd_sc_hd__decap_3
XFILLER_24_113 VGND VGND VPWR VPWR sky130_fd_sc_hd__decap_3
XFILLER_52_433 VGND VGND VPWR VPWR sky130_fd_sc_hd__decap_3
XFILLER_64_293 VGND VGND VPWR VPWR sky130_fd_sc_hd__decap_3
XTAP_TAPCELL_ROW_69_1083 VGND VPWR sky130_fd_sc_hd__tapvpwrvgnd_1
XFILLER_24_168 VGND VGND VPWR VPWR sky130_fd_sc_hd__decap_3
X_4937_ _4937_/A _4937_/B VGND VGND VPWR VPWR _4937_/Y sky130_fd_sc_hd__xnor2_2
XTAP_TAPCELL_ROW_35_675 VGND VPWR sky130_fd_sc_hd__tapvpwrvgnd_1
XANTENNA_20 _7365_/Q VGND VGND VPWR VPWR sky130_fd_sc_hd__diode_2
XANTENNA_31 _5663_/A VGND VGND VPWR VPWR sky130_fd_sc_hd__diode_2
XFILLER_20_330 VGND VGND VPWR VPWR sky130_fd_sc_hd__decap_3
X_4868_ _6999_/Q _4882_/A VGND VGND VPWR VPWR _6999_/D sky130_fd_sc_hd__xnor2_2
XFILLER_20_363 VGND VGND VPWR VPWR sky130_fd_sc_hd__fill_1
XFILLER_20_374 VGND VGND VPWR VPWR sky130_fd_sc_hd__decap_3
X_6607_ _6608_/A VGND VGND VPWR VPWR _6607_/Y sky130_fd_sc_hd__inv_2
X_3819_ _6791_/Q _3926_/B1 _3827_/B1 _6879_/Q VGND VGND VPWR VPWR _3819_/X sky130_fd_sc_hd__a22o_2
XFILLER_20_396 VGND VGND VPWR VPWR sky130_fd_sc_hd__fill_1
XFILLER_21_24 VGND VGND VPWR VPWR sky130_fd_sc_hd__decap_3
X_4799_ _4799_/A _5656_/A VGND VGND VPWR VPWR _4799_/X sky130_fd_sc_hd__or2_2
XFILLER_106_424 VGND VGND VPWR VPWR sky130_fd_sc_hd__decap_3
XFILLER_21_57 VGND VGND VPWR VPWR sky130_fd_sc_hd__decap_3
X_6538_ _6539_/A VGND VGND VPWR VPWR _6538_/Y sky130_fd_sc_hd__inv_2
XFILLER_106_457 VGND VGND VPWR VPWR sky130_fd_sc_hd__decap_3
XFILLER_108_6 VGND VGND VPWR VPWR sky130_fd_sc_hd__decap_3
X_6469_ _6535_/A VGND VGND VPWR VPWR _6469_/Y sky130_fd_sc_hd__inv_2
XFILLER_106_468 VGND VGND VPWR VPWR sky130_fd_sc_hd__decap_3
XFILLER_97_39 VGND VGND VPWR VPWR sky130_fd_sc_hd__decap_3
XTAP_TAPCELL_ROW_7_334 VGND VPWR sky130_fd_sc_hd__tapvpwrvgnd_1
XFILLER_99_190 VGND VGND VPWR VPWR sky130_fd_sc_hd__decap_3
XFILLER_102_641 VGND VGND VPWR VPWR sky130_fd_sc_hd__decap_3
XFILLER_75_503 VGND VGND VPWR VPWR sky130_fd_sc_hd__fill_1
XFILLER_87_352 VGND VGND VPWR VPWR sky130_fd_sc_hd__decap_3
XPHY_EDGE_ROW_102_Right_102 VGND VGND VPWR VPWR sky130_fd_sc_hd__decap_3
XFILLER_101_151 VGND VGND VPWR VPWR sky130_fd_sc_hd__decap_3
XFILLER_47_205 VGND VGND VPWR VPWR sky130_fd_sc_hd__decap_3
XFILLER_75_525 VGND VGND VPWR VPWR sky130_fd_sc_hd__decap_3
XFILLER_87_385 VGND VGND VPWR VPWR sky130_fd_sc_hd__decap_3
XFILLER_87_396 VGND VGND VPWR VPWR sky130_fd_sc_hd__decap_3
XFILLER_101_195 VGND VGND VPWR VPWR sky130_fd_sc_hd__decap_3
XFILLER_47_249 VGND VGND VPWR VPWR sky130_fd_sc_hd__decap_3
XFILLER_75_558 VGND VGND VPWR VPWR sky130_fd_sc_hd__fill_2
XFILLER_28_452 VGND VGND VPWR VPWR sky130_fd_sc_hd__decap_3
XFILLER_46_76 VGND VGND VPWR VPWR sky130_fd_sc_hd__fill_1
XFILLER_62_219 VGND VGND VPWR VPWR sky130_fd_sc_hd__decap_3
XFILLER_90_517 VGND VGND VPWR VPWR sky130_fd_sc_hd__decap_3
XFILLER_90_539 VGND VGND VPWR VPWR sky130_fd_sc_hd__decap_3
XFILLER_15_113 VGND VGND VPWR VPWR sky130_fd_sc_hd__decap_3
XFILLER_43_422 VGND VGND VPWR VPWR sky130_fd_sc_hd__decap_3
XFILLER_43_444 VGND VGND VPWR VPWR sky130_fd_sc_hd__decap_3
XFILLER_55_293 VGND VGND VPWR VPWR sky130_fd_sc_hd__fill_1
XFILLER_83_591 VGND VGND VPWR VPWR sky130_fd_sc_hd__decap_3
XFILLER_102_60 VGND VGND VPWR VPWR sky130_fd_sc_hd__fill_2
XFILLER_31_606 VGND VGND VPWR VPWR sky130_fd_sc_hd__fill_2
XFILLER_70_241 VGND VGND VPWR VPWR sky130_fd_sc_hd__decap_3
XFILLER_24_680 VGND VGND VPWR VPWR sky130_fd_sc_hd__fill_2
XFILLER_11_330 VGND VGND VPWR VPWR sky130_fd_sc_hd__decap_3
XFILLER_23_190 VGND VGND VPWR VPWR sky130_fd_sc_hd__decap_3
XFILLER_30_138 VGND VGND VPWR VPWR sky130_fd_sc_hd__fill_2
XFILLER_62_97 VGND VGND VPWR VPWR sky130_fd_sc_hd__decap_3
XFILLER_11_352 VGND VGND VPWR VPWR sky130_fd_sc_hd__decap_3
XFILLER_7_15 VGND VGND VPWR VPWR sky130_fd_sc_hd__fill_2
XFILLER_7_323 VGND VGND VPWR VPWR sky130_fd_sc_hd__decap_3
XTAP_TAPCELL_ROW_96_1408 VGND VPWR sky130_fd_sc_hd__tapvpwrvgnd_1
XFILLER_11_385 VGND VGND VPWR VPWR sky130_fd_sc_hd__decap_3
XFILLER_7_48 VGND VGND VPWR VPWR sky130_fd_sc_hd__decap_3
XFILLER_109_284 VGND VGND VPWR VPWR sky130_fd_sc_hd__decap_3
XFILLER_7_367 VGND VGND VPWR VPWR sky130_fd_sc_hd__decap_3
XFILLER_112_416 VGND VGND VPWR VPWR sky130_fd_sc_hd__decap_3
XFILLER_98_639 VGND VGND VPWR VPWR sky130_fd_sc_hd__decap_3
XFILLER_98_617 VGND VGND VPWR VPWR sky130_fd_sc_hd__decap_3
XFILLER_112_427 VGND VGND VPWR VPWR sky130_fd_sc_hd__decap_3
XFILLER_23_6 VGND VGND VPWR VPWR sky130_fd_sc_hd__decap_3
XFILLER_78_341 VGND VGND VPWR VPWR sky130_fd_sc_hd__decap_3
XFILLER_78_363 VGND VGND VPWR VPWR sky130_fd_sc_hd__fill_1
XFILLER_66_525 VGND VGND VPWR VPWR sky130_fd_sc_hd__decap_3
XFILLER_66_536 VGND VGND VPWR VPWR sky130_fd_sc_hd__decap_3
XFILLER_78_374 VGND VGND VPWR VPWR sky130_fd_sc_hd__decap_3
XFILLER_93_322 VGND VGND VPWR VPWR sky130_fd_sc_hd__decap_3
XFILLER_93_355 VGND VGND VPWR VPWR sky130_fd_sc_hd__decap_3
XFILLER_19_452 VGND VGND VPWR VPWR sky130_fd_sc_hd__decap_3
XFILLER_93_388 VGND VGND VPWR VPWR sky130_fd_sc_hd__decap_3
XFILLER_34_411 VGND VGND VPWR VPWR sky130_fd_sc_hd__decap_3
XFILLER_93_399 VGND VGND VPWR VPWR sky130_fd_sc_hd__decap_3
XTAP_TAPCELL_ROW_105_1515 VGND VPWR sky130_fd_sc_hd__tapvpwrvgnd_1
XFILLER_34_477 VGND VGND VPWR VPWR sky130_fd_sc_hd__decap_3
XFILLER_21_116 VGND VGND VPWR VPWR sky130_fd_sc_hd__decap_3
XFILLER_21_127 VGND VGND VPWR VPWR sky130_fd_sc_hd__decap_3
XFILLER_34_488 VGND VGND VPWR VPWR sky130_fd_sc_hd__decap_3
XFILLER_14_190 VGND VGND VPWR VPWR sky130_fd_sc_hd__decap_3
XTAP_TAPCELL_ROW_32_634 VGND VPWR sky130_fd_sc_hd__tapvpwrvgnd_1
XTAP_TAPCELL_ROW_60_976 VGND VPWR sky130_fd_sc_hd__tapvpwrvgnd_1
X_4653_ _4648_/Y _4785_/A _4413_/A _4397_/A VGND VGND VPWR VPWR _4653_/Y sky130_fd_sc_hd__a211oi_2
X_7372_ _7403_/CLK _7372_/D _6652_/Y VGND VGND VPWR VPWR _7372_/Q sky130_fd_sc_hd__dfrtp_2
Xhold802 _6745_/Q VGND VGND VPWR VPWR _6745_/D sky130_fd_sc_hd__dlygate4sd3_1
X_3604_ _4938_/A _3604_/B VGND VGND VPWR VPWR _3621_/B sky130_fd_sc_hd__nor2_2
XTAP_TAPCELL_ROW_12_391 VGND VPWR sky130_fd_sc_hd__tapvpwrvgnd_1
Xhold813 _6923_/Q VGND VGND VPWR VPWR _6923_/D sky130_fd_sc_hd__dlygate4sd3_1
Xhold824 _6776_/Q VGND VGND VPWR VPWR _6776_/D sky130_fd_sc_hd__dlygate4sd3_1
Xhold835 _6758_/Q VGND VGND VPWR VPWR _6758_/D sky130_fd_sc_hd__dlygate4sd3_1
Xhold846 _6942_/Q VGND VGND VPWR VPWR _6942_/D sky130_fd_sc_hd__dlygate4sd3_1
X_6323_ _6674_/A VGND VGND VPWR VPWR _6323_/Y sky130_fd_sc_hd__inv_2
X_3535_ _3621_/A _5071_/A _4764_/B VGND VGND VPWR VPWR _3536_/B sky130_fd_sc_hd__and3_2
XTAP_TAPCELL_ROW_116_1655 VGND VPWR sky130_fd_sc_hd__tapvpwrvgnd_1
XTAP_TAPCELL_ROW_116_1644 VGND VPWR sky130_fd_sc_hd__tapvpwrvgnd_1
XFILLER_103_405 VGND VGND VPWR VPWR sky130_fd_sc_hd__decap_3
XFILLER_107_38 VGND VGND VPWR VPWR sky130_fd_sc_hd__decap_3
XFILLER_115_276 VGND VGND VPWR VPWR sky130_fd_sc_hd__decap_3
XFILLER_89_617 VGND VGND VPWR VPWR sky130_fd_sc_hd__decap_3
Xhold857 _7073_/Q VGND VGND VPWR VPWR _7073_/D sky130_fd_sc_hd__dlygate4sd3_1
Xhold868 _7058_/Q VGND VGND VPWR VPWR _7058_/D sky130_fd_sc_hd__dlygate4sd3_1
Xhold879 _7116_/Q VGND VGND VPWR VPWR _7116_/D sky130_fd_sc_hd__dlygate4sd3_1
Xmax_cap576 _6639_/A VGND VGND VPWR VPWR _6640_/A sky130_fd_sc_hd__buf_2
Xmax_cap565 _4273_/Y VGND VGND VPWR VPWR _4994_/A2 sky130_fd_sc_hd__clkdlybuf4s25_1
X_3466_ _7217_/Q _3318_/B _4532_/S _7030_/Q _3465_/X VGND VGND VPWR VPWR _3466_/X
+ sky130_fd_sc_hd__a221o_2
XFILLER_103_449 VGND VGND VPWR VPWR sky130_fd_sc_hd__decap_3
XFILLER_88_138 VGND VGND VPWR VPWR sky130_fd_sc_hd__fill_2
X_5205_ _7226_/Q _5225_/B VGND VGND VPWR VPWR _7226_/D sky130_fd_sc_hd__and2_2
XTAP_TAPCELL_ROW_4_304 VGND VPWR sky130_fd_sc_hd__tapvpwrvgnd_1
XFILLER_97_650 VGND VGND VPWR VPWR sky130_fd_sc_hd__fill_1
XFILLER_111_460 VGND VGND VPWR VPWR sky130_fd_sc_hd__decap_3
XFILLER_111_471 VGND VGND VPWR VPWR sky130_fd_sc_hd__decap_3
XFILLER_29_205 VGND VGND VPWR VPWR sky130_fd_sc_hd__decap_3
XFILLER_69_396 VGND VGND VPWR VPWR sky130_fd_sc_hd__decap_3
XFILLER_84_300 VGND VGND VPWR VPWR sky130_fd_sc_hd__decap_3
XFILLER_96_171 VGND VGND VPWR VPWR sky130_fd_sc_hd__decap_3
X_5136_ _5136_/A0 _5135_/X _5136_/S VGND VGND VPWR VPWR _7251_/D sky130_fd_sc_hd__mux2_2
XFILLER_84_344 VGND VGND VPWR VPWR sky130_fd_sc_hd__decap_3
X_5067_ _5648_/A _5067_/B VGND VGND VPWR VPWR _5068_/C sky130_fd_sc_hd__or2_2
XFILLER_72_517 VGND VGND VPWR VPWR sky130_fd_sc_hd__decap_3
XFILLER_84_377 VGND VGND VPWR VPWR sky130_fd_sc_hd__decap_3
X_4018_ _7150_/Q _5229_/C _4011_/X _4017_/X VGND VGND VPWR VPWR _4018_/X sky130_fd_sc_hd__a211o_2
XFILLER_16_24 VGND VGND VPWR VPWR sky130_fd_sc_hd__decap_3
XFILLER_16_35 VGND VGND VPWR VPWR sky130_fd_sc_hd__decap_3
XFILLER_37_293 VGND VGND VPWR VPWR sky130_fd_sc_hd__decap_3
XFILLER_16_57 VGND VGND VPWR VPWR sky130_fd_sc_hd__fill_2
XFILLER_25_455 VGND VGND VPWR VPWR sky130_fd_sc_hd__fill_1
XFILLER_80_561 VGND VGND VPWR VPWR sky130_fd_sc_hd__decap_3
XTAP_TAPCELL_ROW_80_1209 VGND VPWR sky130_fd_sc_hd__tapvpwrvgnd_1
XFILLER_12_116 VGND VGND VPWR VPWR sky130_fd_sc_hd__decap_3
XFILLER_52_274 VGND VGND VPWR VPWR sky130_fd_sc_hd__decap_3
XFILLER_32_12 VGND VGND VPWR VPWR sky130_fd_sc_hd__decap_3
XFILLER_52_296 VGND VGND VPWR VPWR sky130_fd_sc_hd__decap_3
XFILLER_8_109 VGND VGND VPWR VPWR sky130_fd_sc_hd__decap_3
XFILLER_32_23 VGND VGND VPWR VPWR sky130_fd_sc_hd__decap_3
XFILLER_32_45 VGND VGND VPWR VPWR sky130_fd_sc_hd__decap_3
XFILLER_20_171 VGND VGND VPWR VPWR sky130_fd_sc_hd__decap_3
XFILLER_4_315 VGND VGND VPWR VPWR sky130_fd_sc_hd__decap_3
XFILLER_106_3 VGND VGND VPWR VPWR sky130_fd_sc_hd__fill_2
XFILLER_4_348 VGND VGND VPWR VPWR sky130_fd_sc_hd__decap_3
XFILLER_106_243 VGND VGND VPWR VPWR sky130_fd_sc_hd__decap_3
XFILLER_106_265 VGND VGND VPWR VPWR sky130_fd_sc_hd__decap_3
XTAP_TAPCELL_ROW_91_1338 VGND VPWR sky130_fd_sc_hd__tapvpwrvgnd_1
XTAP_TAPCELL_ROW_91_1349 VGND VPWR sky130_fd_sc_hd__tapvpwrvgnd_1
XFILLER_79_149 VGND VGND VPWR VPWR sky130_fd_sc_hd__decap_3
XFILLER_75_300 VGND VGND VPWR VPWR sky130_fd_sc_hd__decap_3
XFILLER_57_75 VGND VGND VPWR VPWR sky130_fd_sc_hd__decap_3
XFILLER_75_333 VGND VGND VPWR VPWR sky130_fd_sc_hd__decap_3
XFILLER_87_182 VGND VGND VPWR VPWR sky130_fd_sc_hd__decap_3
XFILLER_35_219 VGND VGND VPWR VPWR sky130_fd_sc_hd__decap_3
XFILLER_63_528 VGND VGND VPWR VPWR sky130_fd_sc_hd__decap_3
XFILLER_113_81 VGND VGND VPWR VPWR sky130_fd_sc_hd__decap_3
XFILLER_16_433 VGND VGND VPWR VPWR sky130_fd_sc_hd__decap_3
XFILLER_28_271 VGND VGND VPWR VPWR sky130_fd_sc_hd__decap_3
XFILLER_75_399 VGND VGND VPWR VPWR sky130_fd_sc_hd__decap_3
XFILLER_90_336 VGND VGND VPWR VPWR sky130_fd_sc_hd__decap_3
XFILLER_71_561 VGND VGND VPWR VPWR sky130_fd_sc_hd__decap_3
XFILLER_73_63 VGND VGND VPWR VPWR sky130_fd_sc_hd__decap_3
XFILLER_16_477 VGND VGND VPWR VPWR sky130_fd_sc_hd__decap_3
XFILLER_43_263 VGND VGND VPWR VPWR sky130_fd_sc_hd__decap_3
XFILLER_73_96 VGND VGND VPWR VPWR sky130_fd_sc_hd__decap_3
XFILLER_43_296 VGND VGND VPWR VPWR sky130_fd_sc_hd__decap_3
XTAP_TAPCELL_ROW_100_1456 VGND VPWR sky130_fd_sc_hd__tapvpwrvgnd_1
XFILLER_7_175 VGND VGND VPWR VPWR sky130_fd_sc_hd__decap_3
X_3320_ _5647_/B VGND VGND VPWR VPWR _3326_/A sky130_fd_sc_hd__inv_2
XFILLER_98_60 VGND VGND VPWR VPWR sky130_fd_sc_hd__decap_3
XFILLER_3_381 VGND VGND VPWR VPWR sky130_fd_sc_hd__decap_3
XFILLER_98_447 VGND VGND VPWR VPWR sky130_fd_sc_hd__decap_3
XFILLER_112_268 VGND VGND VPWR VPWR sky130_fd_sc_hd__decap_3
XFILLER_79_650 VGND VGND VPWR VPWR sky130_fd_sc_hd__decap_3
XFILLER_100_419 VGND VGND VPWR VPWR sky130_fd_sc_hd__fill_1
XFILLER_21_3 VGND VGND VPWR VPWR sky130_fd_sc_hd__decap_3
XFILLER_79_683 VGND VGND VPWR VPWR sky130_fd_sc_hd__fill_1
XFILLER_85_108 VGND VGND VPWR VPWR sky130_fd_sc_hd__decap_3
XTAP_TAPCELL_ROW_111_1585 VGND VPWR sky130_fd_sc_hd__tapvpwrvgnd_1
XFILLER_66_344 VGND VGND VPWR VPWR sky130_fd_sc_hd__decap_3
XFILLER_78_182 VGND VGND VPWR VPWR sky130_fd_sc_hd__decap_3
XFILLER_94_642 VGND VGND VPWR VPWR sky130_fd_sc_hd__fill_2
XFILLER_81_303 VGND VGND VPWR VPWR sky130_fd_sc_hd__decap_3
XFILLER_93_152 VGND VGND VPWR VPWR sky130_fd_sc_hd__decap_3
XFILLER_19_293 VGND VGND VPWR VPWR sky130_fd_sc_hd__decap_3
XFILLER_66_399 VGND VGND VPWR VPWR sky130_fd_sc_hd__decap_3
X_6941_ _7404_/CLK _6941_/D VGND VGND VPWR VPWR _6941_/Q sky130_fd_sc_hd__dfxtp_2
XFILLER_81_358 VGND VGND VPWR VPWR sky130_fd_sc_hd__decap_3
X_6872_ _6909_/CLK _6872_/D VGND VGND VPWR VPWR _6872_/Q sky130_fd_sc_hd__dfxtp_2
XTAP_TAPCELL_ROW_66_1042 VGND VPWR sky130_fd_sc_hd__tapvpwrvgnd_1
XFILLER_34_274 VGND VGND VPWR VPWR sky130_fd_sc_hd__decap_3
XTAP_TAPCELL_ROW_17_461 VGND VPWR sky130_fd_sc_hd__tapvpwrvgnd_1
XTAP_TAPCELL_ROW_17_450 VGND VPWR sky130_fd_sc_hd__tapvpwrvgnd_1
XTAP_TAPCELL_ROW_45_792 VGND VPWR sky130_fd_sc_hd__tapvpwrvgnd_1
XFILLER_30_480 VGND VGND VPWR VPWR sky130_fd_sc_hd__decap_3
X_4705_ _6995_/Q _6996_/Q _4963_/A VGND VGND VPWR VPWR _4931_/A sky130_fd_sc_hd__and3_2
XFILLER_8_80 VGND VGND VPWR VPWR sky130_fd_sc_hd__decap_3
XFILLER_8_91 VGND VGND VPWR VPWR sky130_fd_sc_hd__decap_3
X_4636_ _4186_/A _4636_/B VGND VGND VPWR VPWR _4639_/A sky130_fd_sc_hd__and2b_2
XPHY_EDGE_ROW_62_Left_179 VGND VGND VPWR VPWR sky130_fd_sc_hd__decap_3
X_7355_ clkload2/A _7355_/D _6635_/Y VGND VGND VPWR VPWR _7355_/Q sky130_fd_sc_hd__dfrtp_2
Xhold610 _6878_/Q VGND VGND VPWR VPWR _6878_/D sky130_fd_sc_hd__dlygate4sd3_1
Xhold621 _6732_/Q VGND VGND VPWR VPWR _6732_/D sky130_fd_sc_hd__dlygate4sd3_1
XFILLER_116_574 VGND VGND VPWR VPWR sky130_fd_sc_hd__decap_3
XFILLER_89_414 VGND VGND VPWR VPWR sky130_fd_sc_hd__decap_3
Xhold632 _6838_/Q VGND VGND VPWR VPWR _6838_/D sky130_fd_sc_hd__dlygate4sd3_1
Xhold643 _6771_/Q VGND VGND VPWR VPWR _6771_/D sky130_fd_sc_hd__dlygate4sd3_1
Xhold654 _6969_/Q VGND VGND VPWR VPWR _6969_/D sky130_fd_sc_hd__dlygate4sd3_1
X_6306_ _6617_/A VGND VGND VPWR VPWR _6306_/Y sky130_fd_sc_hd__inv_2
X_4567_ _7297_/Q _4567_/B VGND VGND VPWR VPWR _7297_/D sky130_fd_sc_hd__and2_2
XTAP_TAPCELL_ROW_77_1171 VGND VPWR sky130_fd_sc_hd__tapvpwrvgnd_1
XFILLER_103_202 VGND VGND VPWR VPWR sky130_fd_sc_hd__decap_3
XFILLER_116_585 VGND VGND VPWR VPWR sky130_fd_sc_hd__decap_3
XFILLER_89_447 VGND VGND VPWR VPWR sky130_fd_sc_hd__fill_1
X_7286_ clkload8/A _7286_/D _6566_/Y VGND VGND VPWR VPWR _7286_/Q sky130_fd_sc_hd__dfrtp_2
Xhold665 _6818_/Q VGND VGND VPWR VPWR _6818_/D sky130_fd_sc_hd__dlygate4sd3_1
Xhold676 _6733_/Q VGND VGND VPWR VPWR _6733_/D sky130_fd_sc_hd__dlygate4sd3_1
Xhold687 _6895_/Q VGND VGND VPWR VPWR _6895_/D sky130_fd_sc_hd__dlygate4sd3_1
XFILLER_103_246 VGND VGND VPWR VPWR sky130_fd_sc_hd__decap_3
Xhold698 _6941_/Q VGND VGND VPWR VPWR _6941_/D sky130_fd_sc_hd__dlygate4sd3_1
X_3449_ _3449_/A _3449_/B _3449_/C VGND VGND VPWR VPWR _3449_/X sky130_fd_sc_hd__and3_2
XFILLER_57_311 VGND VGND VPWR VPWR sky130_fd_sc_hd__decap_3
XFILLER_69_193 VGND VGND VPWR VPWR sky130_fd_sc_hd__decap_3
XFILLER_84_130 VGND VGND VPWR VPWR sky130_fd_sc_hd__decap_3
XFILLER_85_631 VGND VGND VPWR VPWR sky130_fd_sc_hd__decap_3
XFILLER_94_29 VGND VGND VPWR VPWR sky130_fd_sc_hd__decap_3
XFILLER_97_491 VGND VGND VPWR VPWR sky130_fd_sc_hd__decap_3
X_5119_ _4697_/A _5670_/B _6984_/Q VGND VGND VPWR VPWR _5120_/B sky130_fd_sc_hd__a21oi_2
XFILLER_17_208 VGND VGND VPWR VPWR sky130_fd_sc_hd__decap_3
XFILLER_27_34 VGND VGND VPWR VPWR sky130_fd_sc_hd__decap_3
XFILLER_57_355 VGND VGND VPWR VPWR sky130_fd_sc_hd__decap_3
XPHY_EDGE_ROW_71_Left_188 VGND VGND VPWR VPWR sky130_fd_sc_hd__decap_3
XFILLER_27_78 VGND VGND VPWR VPWR sky130_fd_sc_hd__decap_3
XFILLER_57_399 VGND VGND VPWR VPWR sky130_fd_sc_hd__decap_3
XFILLER_13_425 VGND VGND VPWR VPWR sky130_fd_sc_hd__decap_3
XFILLER_25_263 VGND VGND VPWR VPWR sky130_fd_sc_hd__decap_3
XFILLER_40_200 VGND VGND VPWR VPWR sky130_fd_sc_hd__decap_3
XFILLER_40_211 VGND VGND VPWR VPWR sky130_fd_sc_hd__fill_1
XFILLER_25_296 VGND VGND VPWR VPWR sky130_fd_sc_hd__decap_3
XFILLER_40_244 VGND VGND VPWR VPWR sky130_fd_sc_hd__decap_3
XFILLER_40_277 VGND VGND VPWR VPWR sky130_fd_sc_hd__decap_3
XFILLER_21_491 VGND VGND VPWR VPWR sky130_fd_sc_hd__decap_3
XPHY_EDGE_ROW_80_Left_197 VGND VGND VPWR VPWR sky130_fd_sc_hd__decap_3
XFILLER_107_552 VGND VGND VPWR VPWR sky130_fd_sc_hd__decap_3
XFILLER_4_167 VGND VGND VPWR VPWR sky130_fd_sc_hd__decap_3
XFILLER_68_41 VGND VGND VPWR VPWR sky130_fd_sc_hd__decap_3
XFILLER_0_340 VGND VGND VPWR VPWR sky130_fd_sc_hd__fill_2
XFILLER_48_300 VGND VGND VPWR VPWR sky130_fd_sc_hd__decap_3
XFILLER_67_108 VGND VGND VPWR VPWR sky130_fd_sc_hd__decap_3
XFILLER_67_119 VGND VGND VPWR VPWR sky130_fd_sc_hd__decap_3
XFILLER_68_85 VGND VGND VPWR VPWR sky130_fd_sc_hd__decap_3
XFILLER_76_620 VGND VGND VPWR VPWR sky130_fd_sc_hd__decap_3
XFILLER_48_333 VGND VGND VPWR VPWR sky130_fd_sc_hd__decap_3
XFILLER_76_631 VGND VGND VPWR VPWR sky130_fd_sc_hd__decap_3
XFILLER_88_480 VGND VGND VPWR VPWR sky130_fd_sc_hd__decap_3
XFILLER_75_163 VGND VGND VPWR VPWR sky130_fd_sc_hd__fill_2
XFILLER_91_612 VGND VGND VPWR VPWR sky130_fd_sc_hd__decap_3
XFILLER_36_528 VGND VGND VPWR VPWR sky130_fd_sc_hd__decap_3
XFILLER_63_314 VGND VGND VPWR VPWR sky130_fd_sc_hd__decap_3
XFILLER_75_196 VGND VGND VPWR VPWR sky130_fd_sc_hd__decap_3
XFILLER_90_100 VGND VGND VPWR VPWR sky130_fd_sc_hd__decap_3
XFILLER_91_623 VGND VGND VPWR VPWR sky130_fd_sc_hd__fill_2
Xplace303 _3634_/Y VGND VGND VPWR VPWR _3991_/B sky130_fd_sc_hd__buf_4
XFILLER_16_230 VGND VGND VPWR VPWR sky130_fd_sc_hd__decap_3
XFILLER_63_358 VGND VGND VPWR VPWR sky130_fd_sc_hd__decap_3
XFILLER_91_689 VGND VGND VPWR VPWR sky130_fd_sc_hd__decap_3
Xplace336 _4349_/B1 VGND VGND VPWR VPWR _4430_/A2 sky130_fd_sc_hd__buf_2
Xplace325 _4205_/A VGND VGND VPWR VPWR _4432_/B1 sky130_fd_sc_hd__buf_2
Xplace314 _4567_/B VGND VGND VPWR VPWR _4583_/B sky130_fd_sc_hd__buf_2
XFILLER_16_274 VGND VGND VPWR VPWR sky130_fd_sc_hd__decap_3
XFILLER_31_200 VGND VGND VPWR VPWR sky130_fd_sc_hd__decap_3
Xplace369 _4188_/C1 VGND VGND VPWR VPWR _4429_/C1 sky130_fd_sc_hd__buf_2
Xplace358 _4417_/A2 VGND VGND VPWR VPWR _4946_/S sky130_fd_sc_hd__buf_2
Xplace347 _4394_/B VGND VGND VPWR VPWR _4435_/B1 sky130_fd_sc_hd__buf_2
XFILLER_31_233 VGND VGND VPWR VPWR sky130_fd_sc_hd__decap_3
XTAP_TAPCELL_ROW_14_420 VGND VPWR sky130_fd_sc_hd__tapvpwrvgnd_1
XTAP_TAPCELL_ROW_42_751 VGND VPWR sky130_fd_sc_hd__tapvpwrvgnd_1
XFILLER_69_3 VGND VGND VPWR VPWR sky130_fd_sc_hd__fill_2
X_4421_ _7240_/Q _4430_/A2 _4430_/B1 _7176_/Q _4420_/X VGND VGND VPWR VPWR _4421_/X
+ sky130_fd_sc_hd__a221o_2
XTAP_TAPCELL_ROW_113_1603 VGND VPWR sky130_fd_sc_hd__tapvpwrvgnd_1
XFILLER_113_500 VGND VGND VPWR VPWR sky130_fd_sc_hd__decap_3
XFILLER_113_511 VGND VGND VPWR VPWR sky130_fd_sc_hd__decap_3
X_7140_ _7362_/CLK _7140_/D _6420_/Y VGND VGND VPWR VPWR _7140_/Q sky130_fd_sc_hd__dfrtp_2
X_4352_ _7289_/Q _5080_/S _3409_/X _7161_/Q _4351_/X VGND VGND VPWR VPWR _4352_/X
+ sky130_fd_sc_hd__a221o_2
X_7071_ _7364_/CLK _7071_/D _6351_/Y VGND VGND VPWR VPWR _7071_/Q sky130_fd_sc_hd__dfrtp_2
X_4283_ _7094_/Q _4351_/A2 _4351_/B1 _7126_/Q VGND VGND VPWR VPWR _4283_/X sky130_fd_sc_hd__a22o_2
X_3303_ _4467_/A _3519_/B _3302_/X VGND VGND VPWR VPWR _6981_/D sky130_fd_sc_hd__o21a_4
XFILLER_98_244 VGND VGND VPWR VPWR sky130_fd_sc_hd__decap_3
XFILLER_100_216 VGND VGND VPWR VPWR sky130_fd_sc_hd__decap_3
XFILLER_113_588 VGND VGND VPWR VPWR sky130_fd_sc_hd__fill_2
XFILLER_58_108 VGND VGND VPWR VPWR sky130_fd_sc_hd__fill_2
XFILLER_86_439 VGND VGND VPWR VPWR sky130_fd_sc_hd__decap_3
XFILLER_98_299 VGND VGND VPWR VPWR sky130_fd_sc_hd__decap_3
XFILLER_98_277 VGND VGND VPWR VPWR sky130_fd_sc_hd__decap_3
XFILLER_100_249 VGND VGND VPWR VPWR sky130_fd_sc_hd__decap_3
XFILLER_67_620 VGND VGND VPWR VPWR sky130_fd_sc_hd__decap_3
XFILLER_79_491 VGND VGND VPWR VPWR sky130_fd_sc_hd__fill_2
XFILLER_39_366 VGND VGND VPWR VPWR sky130_fd_sc_hd__decap_3
XFILLER_66_141 VGND VGND VPWR VPWR sky130_fd_sc_hd__decap_3
XFILLER_67_686 VGND VGND VPWR VPWR sky130_fd_sc_hd__decap_3
XFILLER_82_612 VGND VGND VPWR VPWR sky130_fd_sc_hd__decap_3
XFILLER_66_174 VGND VGND VPWR VPWR sky130_fd_sc_hd__decap_3
XFILLER_66_185 VGND VGND VPWR VPWR sky130_fd_sc_hd__decap_3
XFILLER_82_645 VGND VGND VPWR VPWR sky130_fd_sc_hd__fill_1
XFILLER_94_483 VGND VGND VPWR VPWR sky130_fd_sc_hd__decap_3
XFILLER_94_494 VGND VGND VPWR VPWR sky130_fd_sc_hd__decap_3
XFILLER_54_347 VGND VGND VPWR VPWR sky130_fd_sc_hd__decap_3
X_6924_ _7390_/CLK _6924_/D VGND VGND VPWR VPWR _6924_/Q sky130_fd_sc_hd__dfxtp_2
XFILLER_22_200 VGND VGND VPWR VPWR sky130_fd_sc_hd__decap_3
XFILLER_81_166 VGND VGND VPWR VPWR sky130_fd_sc_hd__fill_2
XFILLER_22_233 VGND VGND VPWR VPWR sky130_fd_sc_hd__decap_3
Xfanout26 _6664_/A VGND VGND VPWR VPWR _6562_/A sky130_fd_sc_hd__buf_2
Xfanout37 fanout38/X VGND VGND VPWR VPWR _6644_/A sky130_fd_sc_hd__buf_2
X_6855_ _6929_/CLK _6855_/D VGND VGND VPWR VPWR _6855_/Q sky130_fd_sc_hd__dfxtp_2
XFILLER_13_14 VGND VGND VPWR VPWR sky130_fd_sc_hd__decap_3
Xfanout48 wire582/X VGND VGND VPWR VPWR _6385_/A sky130_fd_sc_hd__buf_2
Xfanout59 _6616_/A VGND VGND VPWR VPWR _6675_/A sky130_fd_sc_hd__buf_2
X_6786_ _7351_/CLK _6786_/D VGND VGND VPWR VPWR _6786_/Q sky130_fd_sc_hd__dfxtp_2
XFILLER_13_47 VGND VGND VPWR VPWR sky130_fd_sc_hd__fill_2
XFILLER_22_299 VGND VGND VPWR VPWR sky130_fd_sc_hd__decap_3
X_5737_ _7374_/Q hold912/X _5737_/S VGND VGND VPWR VPWR _6718_/D sky130_fd_sc_hd__mux2_2
XTAP_TAPCELL_ROW_79_1200 VGND VPWR sky130_fd_sc_hd__tapvpwrvgnd_1
XFILLER_13_69 VGND VGND VPWR VPWR sky130_fd_sc_hd__decap_3
XFILLER_108_327 VGND VGND VPWR VPWR sky130_fd_sc_hd__decap_3
XFILLER_89_18 VGND VGND VPWR VPWR sky130_fd_sc_hd__decap_3
X_5668_ _5668_/A _5668_/B VGND VGND VPWR VPWR _6980_/D sky130_fd_sc_hd__or2_2
XTAP_TAPCELL_ROW_20_489 VGND VPWR sky130_fd_sc_hd__tapvpwrvgnd_1
XFILLER_2_605 VGND VGND VPWR VPWR sky130_fd_sc_hd__decap_3
X_4619_ _5086_/A _4619_/B _5101_/B _5073_/A VGND VGND VPWR VPWR _4619_/Y sky130_fd_sc_hd__nor4_2
XFILLER_104_511 VGND VGND VPWR VPWR sky130_fd_sc_hd__decap_3
XFILLER_116_371 VGND VGND VPWR VPWR sky130_fd_sc_hd__decap_3
XFILLER_116_382 VGND VGND VPWR VPWR sky130_fd_sc_hd__decap_3
X_7338_ _7338_/CLK _7338_/D _6618_/Y VGND VGND VPWR VPWR _7338_/Q sky130_fd_sc_hd__dfrtp_2
XFILLER_104_533 VGND VGND VPWR VPWR sky130_fd_sc_hd__fill_2
XFILLER_104_544 VGND VGND VPWR VPWR sky130_fd_sc_hd__decap_3
XFILLER_116_393 VGND VGND VPWR VPWR sky130_fd_sc_hd__decap_3
XFILLER_1_137 VGND VGND VPWR VPWR sky130_fd_sc_hd__decap_3
X_7269_ _7365_/CLK _7269_/D _6549_/Y VGND VGND VPWR VPWR _7269_/Q sky130_fd_sc_hd__dfrtp_2
XFILLER_49_119 VGND VGND VPWR VPWR sky130_fd_sc_hd__decap_3
XFILLER_77_417 VGND VGND VPWR VPWR sky130_fd_sc_hd__decap_3
XFILLER_89_266 VGND VGND VPWR VPWR sky130_fd_sc_hd__decap_3
XFILLER_38_44 VGND VGND VPWR VPWR sky130_fd_sc_hd__fill_2
XFILLER_38_66 VGND VGND VPWR VPWR sky130_fd_sc_hd__decap_3
XFILLER_38_88 VGND VGND VPWR VPWR sky130_fd_sc_hd__decap_3
XFILLER_85_461 VGND VGND VPWR VPWR sky130_fd_sc_hd__fill_1
Xhold1140 _7135_/Q VGND VGND VPWR VPWR _5396_/A0 sky130_fd_sc_hd__dlygate4sd3_1
Xhold1151 _7331_/Q VGND VGND VPWR VPWR _4497_/A0 sky130_fd_sc_hd__dlygate4sd3_1
XFILLER_45_325 VGND VGND VPWR VPWR sky130_fd_sc_hd__decap_3
XFILLER_57_174 VGND VGND VPWR VPWR sky130_fd_sc_hd__decap_3
XFILLER_72_122 VGND VGND VPWR VPWR sky130_fd_sc_hd__decap_3
XFILLER_85_483 VGND VGND VPWR VPWR sky130_fd_sc_hd__decap_3
Xhold1162 _7216_/Q VGND VGND VPWR VPWR _5225_/A sky130_fd_sc_hd__dlygate4sd3_1
Xhold1173 _7167_/Q VGND VGND VPWR VPWR _5327_/A0 sky130_fd_sc_hd__dlygate4sd3_1
Xhold1184 _7247_/Q VGND VGND VPWR VPWR _5159_/A0 sky130_fd_sc_hd__dlygate4sd3_1
XFILLER_26_550 VGND VGND VPWR VPWR sky130_fd_sc_hd__decap_3
XFILLER_54_32 VGND VGND VPWR VPWR sky130_fd_sc_hd__decap_3
XFILLER_72_144 VGND VGND VPWR VPWR sky130_fd_sc_hd__decap_3
Xhold1195 _7292_/Q VGND VGND VPWR VPWR _4577_/A sky130_fd_sc_hd__dlygate4sd3_1
XFILLER_60_328 VGND VGND VPWR VPWR sky130_fd_sc_hd__decap_3
XFILLER_72_166 VGND VGND VPWR VPWR sky130_fd_sc_hd__fill_1
XFILLER_72_177 VGND VGND VPWR VPWR sky130_fd_sc_hd__decap_3
XTAP_TAPCELL_ROW_28_589 VGND VPWR sky130_fd_sc_hd__tapvpwrvgnd_1
XFILLER_54_76 VGND VGND VPWR VPWR sky130_fd_sc_hd__fill_1
XPHY_EDGE_ROW_109_Left_226 VGND VGND VPWR VPWR sky130_fd_sc_hd__decap_3
XFILLER_110_82 VGND VGND VPWR VPWR sky130_fd_sc_hd__fill_2
XFILLER_9_237 VGND VGND VPWR VPWR sky130_fd_sc_hd__decap_3
Xclkload18 _6968_/CLK VGND VGND VPWR VPWR clkload18/X sky130_fd_sc_hd__clkbuf_8
Xclkload29 _7365_/CLK VGND VGND VPWR VPWR clkload29/X sky130_fd_sc_hd__clkbuf_8
XFILLER_5_432 VGND VGND VPWR VPWR sky130_fd_sc_hd__decap_3
XFILLER_107_382 VGND VGND VPWR VPWR sky130_fd_sc_hd__decap_3
XFILLER_107_393 VGND VGND VPWR VPWR sky130_fd_sc_hd__decap_3
XFILLER_0_181 VGND VGND VPWR VPWR sky130_fd_sc_hd__fill_1
XFILLER_110_536 VGND VGND VPWR VPWR sky130_fd_sc_hd__fill_1
XFILLER_95_225 VGND VGND VPWR VPWR sky130_fd_sc_hd__decap_3
XFILLER_48_152 VGND VGND VPWR VPWR sky130_fd_sc_hd__decap_3
XFILLER_95_72 VGND VGND VPWR VPWR sky130_fd_sc_hd__decap_3
XFILLER_95_83 VGND VGND VPWR VPWR sky130_fd_sc_hd__fill_1
XFILLER_36_336 VGND VGND VPWR VPWR sky130_fd_sc_hd__fill_1
XFILLER_76_472 VGND VGND VPWR VPWR sky130_fd_sc_hd__decap_3
XFILLER_76_483 VGND VGND VPWR VPWR sky130_fd_sc_hd__decap_3
XTAP_TAPCELL_ROW_47_821 VGND VPWR sky130_fd_sc_hd__tapvpwrvgnd_1
XTAP_TAPCELL_ROW_47_810 VGND VPWR sky130_fd_sc_hd__tapvpwrvgnd_1
XFILLER_63_122 VGND VGND VPWR VPWR sky130_fd_sc_hd__decap_3
XFILLER_63_133 VGND VGND VPWR VPWR sky130_fd_sc_hd__decap_3
XFILLER_64_656 VGND VGND VPWR VPWR sky130_fd_sc_hd__decap_3
XFILLER_64_678 VGND VGND VPWR VPWR sky130_fd_sc_hd__decap_3
XFILLER_17_550 VGND VGND VPWR VPWR sky130_fd_sc_hd__fill_2
XFILLER_51_317 VGND VGND VPWR VPWR sky130_fd_sc_hd__decap_3
XFILLER_63_177 VGND VGND VPWR VPWR sky130_fd_sc_hd__decap_3
X_4970_ _3604_/B _4950_/B _4967_/B _5033_/B2 VGND VGND VPWR VPWR _4970_/X sky130_fd_sc_hd__a22o_2
XFILLER_44_380 VGND VGND VPWR VPWR sky130_fd_sc_hd__decap_3
X_3921_ _6914_/Q _3926_/A2 _3925_/A2 _6688_/Q VGND VGND VPWR VPWR _3921_/X sky130_fd_sc_hd__a22o_2
XTAP_TAPCELL_ROW_63_1012 VGND VPWR sky130_fd_sc_hd__tapvpwrvgnd_1
X_6640_ _6640_/A VGND VGND VPWR VPWR _6640_/Y sky130_fd_sc_hd__inv_2
X_3852_ _6748_/Q _3852_/A2 _3852_/B1 _6742_/Q VGND VGND VPWR VPWR _3852_/X sky130_fd_sc_hd__a22o_2
XFILLER_32_586 VGND VGND VPWR VPWR sky130_fd_sc_hd__fill_2
X_6571_ _6632_/A VGND VGND VPWR VPWR _6571_/Y sky130_fd_sc_hd__inv_2
X_3783_ _6812_/Q _5660_/B _3847_/B1 _6822_/Q _3782_/X VGND VGND VPWR VPWR _3783_/X
+ sky130_fd_sc_hd__a221o_2
Xoutput501 _3525_/B VGND VGND VPWR VPWR instruction_out[14] sky130_fd_sc_hd__clkdlybuf4s25_1
Xoutput545 _7006_/Q VGND VGND VPWR VPWR pc_out[29] sky130_fd_sc_hd__clkdlybuf4s25_1
Xoutput534 _6996_/Q VGND VGND VPWR VPWR pc_out[19] sky130_fd_sc_hd__clkdlybuf4s25_1
Xoutput523 _5646_/Y VGND VGND VPWR VPWR instruction_out[9] sky130_fd_sc_hd__clkdlybuf4s25_1
Xoutput512 _5649_/X VGND VGND VPWR VPWR instruction_out[26] sky130_fd_sc_hd__clkdlybuf4s25_1
X_4404_ _7306_/Q _4879_/S _4434_/A2 _7114_/Q VGND VGND VPWR VPWR _4404_/X sky130_fd_sc_hd__a22o_2
XFILLER_99_520 VGND VGND VPWR VPWR sky130_fd_sc_hd__decap_3
X_7123_ clkload8/A _7123_/D _6403_/Y VGND VGND VPWR VPWR _7123_/Q sky130_fd_sc_hd__dfrtp_2
X_4335_ _7287_/Q _5136_/S _3417_/X _7095_/Q VGND VGND VPWR VPWR _4336_/C sky130_fd_sc_hd__a22o_2
XTAP_TAPCELL_ROW_74_1141 VGND VPWR sky130_fd_sc_hd__tapvpwrvgnd_1
XFILLER_101_503 VGND VGND VPWR VPWR sky130_fd_sc_hd__fill_1
XFILLER_101_514 VGND VGND VPWR VPWR sky130_fd_sc_hd__decap_3
XFILLER_113_352 VGND VGND VPWR VPWR sky130_fd_sc_hd__decap_3
XFILLER_59_417 VGND VGND VPWR VPWR sky130_fd_sc_hd__decap_3
XFILLER_99_575 VGND VGND VPWR VPWR sky130_fd_sc_hd__decap_3
XFILLER_113_385 VGND VGND VPWR VPWR sky130_fd_sc_hd__decap_3
XFILLER_86_236 VGND VGND VPWR VPWR sky130_fd_sc_hd__decap_3
X_7054_ _7368_/CLK _7054_/D _6334_/Y VGND VGND VPWR VPWR _7054_/Q sky130_fd_sc_hd__dfrtp_2
X_4266_ _7294_/Q _5080_/S _4351_/A2 _7102_/Q VGND VGND VPWR VPWR _4271_/A sky130_fd_sc_hd__a22o_2
X_4197_ _7199_/Q _3964_/S _4505_/S _7044_/Q _4196_/X VGND VGND VPWR VPWR _4197_/X
+ sky130_fd_sc_hd__a221o_2
XFILLER_27_325 VGND VGND VPWR VPWR sky130_fd_sc_hd__decap_3
XFILLER_39_185 VGND VGND VPWR VPWR sky130_fd_sc_hd__decap_3
XFILLER_67_472 VGND VGND VPWR VPWR sky130_fd_sc_hd__decap_3
XFILLER_27_358 VGND VGND VPWR VPWR sky130_fd_sc_hd__decap_3
XFILLER_54_144 VGND VGND VPWR VPWR sky130_fd_sc_hd__decap_3
XFILLER_82_442 VGND VGND VPWR VPWR sky130_fd_sc_hd__decap_3
XFILLER_54_177 VGND VGND VPWR VPWR sky130_fd_sc_hd__decap_3
XFILLER_70_604 VGND VGND VPWR VPWR sky130_fd_sc_hd__decap_3
XFILLER_82_475 VGND VGND VPWR VPWR sky130_fd_sc_hd__fill_1
XFILLER_82_497 VGND VGND VPWR VPWR sky130_fd_sc_hd__decap_3
XFILLER_91_19 VGND VGND VPWR VPWR sky130_fd_sc_hd__decap_3
XFILLER_23_520 VGND VGND VPWR VPWR sky130_fd_sc_hd__fill_1
XFILLER_70_648 VGND VGND VPWR VPWR sky130_fd_sc_hd__decap_3
X_6907_ _6929_/CLK _6907_/D VGND VGND VPWR VPWR _6907_/Q sky130_fd_sc_hd__dfxtp_2
XTAP_TAPCELL_ROW_85_1270 VGND VPWR sky130_fd_sc_hd__tapvpwrvgnd_1
XTAP_TAPCELL_ROW_25_548 VGND VPWR sky130_fd_sc_hd__tapvpwrvgnd_1
XFILLER_24_35 VGND VGND VPWR VPWR sky130_fd_sc_hd__decap_3
X_6838_ _6978_/CLK _6838_/D VGND VGND VPWR VPWR _6838_/Q sky130_fd_sc_hd__dfxtp_2
XFILLER_10_214 VGND VGND VPWR VPWR sky130_fd_sc_hd__fill_1
XFILLER_50_372 VGND VGND VPWR VPWR sky130_fd_sc_hd__decap_3
XFILLER_109_614 VGND VGND VPWR VPWR sky130_fd_sc_hd__fill_2
XFILLER_10_236 VGND VGND VPWR VPWR sky130_fd_sc_hd__fill_1
XFILLER_10_247 VGND VGND VPWR VPWR sky130_fd_sc_hd__decap_3
X_6769_ _6968_/CLK _6769_/D VGND VGND VPWR VPWR _6769_/Q sky130_fd_sc_hd__dfxtp_2
XFILLER_10_269 VGND VGND VPWR VPWR sky130_fd_sc_hd__decap_3
XFILLER_40_12 VGND VGND VPWR VPWR sky130_fd_sc_hd__decap_3
XFILLER_6_218 VGND VGND VPWR VPWR sky130_fd_sc_hd__decap_3
XFILLER_40_56 VGND VGND VPWR VPWR sky130_fd_sc_hd__decap_3
XFILLER_40_78 VGND VGND VPWR VPWR sky130_fd_sc_hd__decap_3
XFILLER_108_179 VGND VGND VPWR VPWR sky130_fd_sc_hd__decap_3
XFILLER_104_330 VGND VGND VPWR VPWR sky130_fd_sc_hd__decap_3
XFILLER_116_190 VGND VGND VPWR VPWR sky130_fd_sc_hd__decap_3
XFILLER_104_363 VGND VGND VPWR VPWR sky130_fd_sc_hd__fill_1
XFILLER_49_54 VGND VGND VPWR VPWR sky130_fd_sc_hd__fill_2
XFILLER_104_385 VGND VGND VPWR VPWR sky130_fd_sc_hd__decap_3
XFILLER_105_60 VGND VGND VPWR VPWR sky130_fd_sc_hd__fill_1
XFILLER_100_580 VGND VGND VPWR VPWR sky130_fd_sc_hd__decap_3
XFILLER_105_93 VGND VGND VPWR VPWR sky130_fd_sc_hd__decap_3
XFILLER_58_472 VGND VGND VPWR VPWR sky130_fd_sc_hd__decap_3
XFILLER_58_494 VGND VGND VPWR VPWR sky130_fd_sc_hd__decap_3
XFILLER_92_217 VGND VGND VPWR VPWR sky130_fd_sc_hd__decap_3
XFILLER_18_336 VGND VGND VPWR VPWR sky130_fd_sc_hd__decap_3
XFILLER_45_122 VGND VGND VPWR VPWR sky130_fd_sc_hd__decap_3
XFILLER_46_645 VGND VGND VPWR VPWR sky130_fd_sc_hd__decap_3
XFILLER_65_53 VGND VGND VPWR VPWR sky130_fd_sc_hd__decap_3
XFILLER_73_431 VGND VGND VPWR VPWR sky130_fd_sc_hd__decap_3
XFILLER_18_369 VGND VGND VPWR VPWR sky130_fd_sc_hd__decap_3
XFILLER_33_306 VGND VGND VPWR VPWR sky130_fd_sc_hd__decap_3
XFILLER_45_155 VGND VGND VPWR VPWR sky130_fd_sc_hd__decap_3
XFILLER_60_103 VGND VGND VPWR VPWR sky130_fd_sc_hd__decap_3
XFILLER_73_475 VGND VGND VPWR VPWR sky130_fd_sc_hd__decap_3
XFILLER_45_188 VGND VGND VPWR VPWR sky130_fd_sc_hd__decap_3
XFILLER_60_125 VGND VGND VPWR VPWR sky130_fd_sc_hd__decap_3
XFILLER_60_136 VGND VGND VPWR VPWR sky130_fd_sc_hd__decap_3
XFILLER_81_41 VGND VGND VPWR VPWR sky130_fd_sc_hd__decap_3
XFILLER_81_63 VGND VGND VPWR VPWR sky130_fd_sc_hd__decap_3
XFILLER_14_586 VGND VGND VPWR VPWR sky130_fd_sc_hd__fill_2
XTAP_TAPCELL_ROW_99_1439 VGND VPWR sky130_fd_sc_hd__tapvpwrvgnd_1
XPHY_EDGE_ROW_116_Right_116 VGND VGND VPWR VPWR sky130_fd_sc_hd__decap_3
XFILLER_53_6 VGND VGND VPWR VPWR sky130_fd_sc_hd__decap_3
XFILLER_5_262 VGND VGND VPWR VPWR sky130_fd_sc_hd__decap_3
XFILLER_107_190 VGND VGND VPWR VPWR sky130_fd_sc_hd__decap_3
XFILLER_5_284 VGND VGND VPWR VPWR sky130_fd_sc_hd__decap_3
XFILLER_68_203 VGND VGND VPWR VPWR sky130_fd_sc_hd__decap_3
XFILLER_96_501 VGND VGND VPWR VPWR sky130_fd_sc_hd__decap_3
X_4120_ _7300_/Q _4946_/S _4218_/A2 _7108_/Q VGND VGND VPWR VPWR _4120_/X sky130_fd_sc_hd__a22o_2
XFILLER_110_355 VGND VGND VPWR VPWR sky130_fd_sc_hd__decap_3
XFILLER_96_578 VGND VGND VPWR VPWR sky130_fd_sc_hd__fill_1
XFILLER_96_589 VGND VGND VPWR VPWR sky130_fd_sc_hd__fill_2
XFILLER_83_217 VGND VGND VPWR VPWR sky130_fd_sc_hd__decap_3
XFILLER_83_228 VGND VGND VPWR VPWR sky130_fd_sc_hd__decap_3
XFILLER_64_453 VGND VGND VPWR VPWR sky130_fd_sc_hd__decap_3
XFILLER_76_291 VGND VGND VPWR VPWR sky130_fd_sc_hd__decap_3
XTAP_TAPCELL_ROW_108_1546 VGND VPWR sky130_fd_sc_hd__tapvpwrvgnd_1
XFILLER_36_155 VGND VGND VPWR VPWR sky130_fd_sc_hd__decap_3
XFILLER_101_29 VGND VGND VPWR VPWR sky130_fd_sc_hd__decap_3
XFILLER_24_328 VGND VGND VPWR VPWR sky130_fd_sc_hd__decap_3
XFILLER_36_188 VGND VGND VPWR VPWR sky130_fd_sc_hd__decap_3
XFILLER_64_497 VGND VGND VPWR VPWR sky130_fd_sc_hd__decap_3
XFILLER_91_294 VGND VGND VPWR VPWR sky130_fd_sc_hd__decap_3
X_4953_ _4186_/Y _4381_/A _4969_/C _3522_/Y VGND VGND VPWR VPWR _4953_/Y sky130_fd_sc_hd__a31oi_2
X_3904_ _5138_/S _3904_/B VGND VGND VPWR VPWR _3904_/Y sky130_fd_sc_hd__nand2_2
X_6623_ _6672_/A VGND VGND VPWR VPWR _6623_/Y sky130_fd_sc_hd__inv_2
X_4884_ _4884_/A _4904_/B VGND VGND VPWR VPWR _4884_/X sky130_fd_sc_hd__or2_2
XTAP_TAPCELL_ROW_50_849 VGND VPWR sky130_fd_sc_hd__tapvpwrvgnd_1
XTAP_TAPCELL_ROW_22_518 VGND VPWR sky130_fd_sc_hd__tapvpwrvgnd_1
X_3835_ _6725_/Q _3852_/A2 _3853_/A2 _6975_/Q VGND VGND VPWR VPWR _3835_/X sky130_fd_sc_hd__a22o_2
XFILLER_20_589 VGND VGND VPWR VPWR sky130_fd_sc_hd__decap_3
X_6554_ _6584_/A VGND VGND VPWR VPWR _6554_/Y sky130_fd_sc_hd__inv_2
X_3766_ _3766_/A1 _4466_/A _4927_/B VGND VGND VPWR VPWR _7394_/D sky130_fd_sc_hd__a21o_2
X_6485_ _6616_/A VGND VGND VPWR VPWR _6485_/Y sky130_fd_sc_hd__inv_2
XFILLER_105_116 VGND VGND VPWR VPWR sky130_fd_sc_hd__decap_3
XFILLER_10_37 VGND VGND VPWR VPWR sky130_fd_sc_hd__decap_3
X_3697_ _3629_/A _3696_/X _3753_/B1 VGND VGND VPWR VPWR _3697_/Y sky130_fd_sc_hd__a21oi_2
XFILLER_10_59 VGND VGND VPWR VPWR sky130_fd_sc_hd__fill_1
XFILLER_59_203 VGND VGND VPWR VPWR sky130_fd_sc_hd__decap_3
X_5367_ _5367_/A0 _4734_/X _5383_/S VGND VGND VPWR VPWR _7149_/D sky130_fd_sc_hd__mux2_2
XFILLER_99_361 VGND VGND VPWR VPWR sky130_fd_sc_hd__decap_3
XFILLER_101_311 VGND VGND VPWR VPWR sky130_fd_sc_hd__decap_3
XFILLER_101_322 VGND VGND VPWR VPWR sky130_fd_sc_hd__decap_3
XFILLER_59_225 VGND VGND VPWR VPWR sky130_fd_sc_hd__decap_3
XFILLER_87_523 VGND VGND VPWR VPWR sky130_fd_sc_hd__fill_1
X_7106_ _7362_/CLK _7106_/D _6386_/Y VGND VGND VPWR VPWR _7106_/Q sky130_fd_sc_hd__dfrtp_2
X_5298_ _5298_/A0 _4734_/X _5325_/S VGND VGND VPWR VPWR _7181_/D sky130_fd_sc_hd__mux2_2
X_4318_ _7290_/Q _4510_/S _4348_/A2 _7162_/Q _4317_/X VGND VGND VPWR VPWR _4318_/X
+ sky130_fd_sc_hd__a221o_2
XFILLER_101_366 VGND VGND VPWR VPWR sky130_fd_sc_hd__decap_3
XFILLER_19_46 VGND VGND VPWR VPWR sky130_fd_sc_hd__decap_3
XFILLER_87_567 VGND VGND VPWR VPWR sky130_fd_sc_hd__decap_3
X_7037_ clkload2/A _7037_/D _6317_/Y VGND VGND VPWR VPWR _7037_/Q sky130_fd_sc_hd__dfrtp_2
X_4249_ _7069_/Q _4265_/B _4205_/A VGND VGND VPWR VPWR _4626_/C sky130_fd_sc_hd__o21a_2
XFILLER_101_399 VGND VGND VPWR VPWR sky130_fd_sc_hd__decap_3
XFILLER_19_57 VGND VGND VPWR VPWR sky130_fd_sc_hd__decap_3
XFILLER_28_601 VGND VGND VPWR VPWR sky130_fd_sc_hd__fill_2
XFILLER_74_239 VGND VGND VPWR VPWR sky130_fd_sc_hd__decap_3
XTAP_TAPCELL_ROW_58_949 VGND VPWR sky130_fd_sc_hd__tapvpwrvgnd_1
XFILLER_27_111 VGND VGND VPWR VPWR sky130_fd_sc_hd__fill_1
XFILLER_27_122 VGND VGND VPWR VPWR sky130_fd_sc_hd__decap_3
XFILLER_28_645 VGND VGND VPWR VPWR sky130_fd_sc_hd__fill_2
XFILLER_55_442 VGND VGND VPWR VPWR sky130_fd_sc_hd__decap_3
XFILLER_27_155 VGND VGND VPWR VPWR sky130_fd_sc_hd__decap_3
XFILLER_42_103 VGND VGND VPWR VPWR sky130_fd_sc_hd__decap_3
XFILLER_55_464 VGND VGND VPWR VPWR sky130_fd_sc_hd__decap_3
XFILLER_70_412 VGND VGND VPWR VPWR sky130_fd_sc_hd__decap_3
XFILLER_82_250 VGND VGND VPWR VPWR sky130_fd_sc_hd__fill_2
XTAP_TAPCELL_ROW_2_276 VGND VPWR sky130_fd_sc_hd__tapvpwrvgnd_1
XFILLER_15_328 VGND VGND VPWR VPWR sky130_fd_sc_hd__decap_3
XFILLER_30_309 VGND VGND VPWR VPWR sky130_fd_sc_hd__fill_1
XFILLER_70_456 VGND VGND VPWR VPWR sky130_fd_sc_hd__decap_3
XFILLER_23_372 VGND VGND VPWR VPWR sky130_fd_sc_hd__decap_3
XFILLER_70_489 VGND VGND VPWR VPWR sky130_fd_sc_hd__decap_3
XFILLER_50_180 VGND VGND VPWR VPWR sky130_fd_sc_hd__decap_3
XFILLER_51_66 VGND VGND VPWR VPWR sky130_fd_sc_hd__fill_1
XFILLER_109_455 VGND VGND VPWR VPWR sky130_fd_sc_hd__decap_3
XFILLER_2_210 VGND VGND VPWR VPWR sky130_fd_sc_hd__decap_3
XFILLER_105_650 VGND VGND VPWR VPWR sky130_fd_sc_hd__fill_1
XFILLER_111_119 VGND VGND VPWR VPWR sky130_fd_sc_hd__decap_3
XFILLER_76_41 VGND VGND VPWR VPWR sky130_fd_sc_hd__decap_3
XFILLER_65_217 VGND VGND VPWR VPWR sky130_fd_sc_hd__decap_3
XFILLER_65_228 VGND VGND VPWR VPWR sky130_fd_sc_hd__decap_3
XFILLER_76_74 VGND VGND VPWR VPWR sky130_fd_sc_hd__decap_3
XFILLER_78_589 VGND VGND VPWR VPWR sky130_fd_sc_hd__decap_3
XFILLER_46_442 VGND VGND VPWR VPWR sky130_fd_sc_hd__decap_3
XFILLER_18_144 VGND VGND VPWR VPWR sky130_fd_sc_hd__fill_1
XFILLER_73_272 VGND VGND VPWR VPWR sky130_fd_sc_hd__decap_3
XFILLER_33_147 VGND VGND VPWR VPWR sky130_fd_sc_hd__decap_3
XFILLER_33_169 VGND VGND VPWR VPWR sky130_fd_sc_hd__decap_3
XFILLER_61_467 VGND VGND VPWR VPWR sky130_fd_sc_hd__decap_3
XFILLER_92_73 VGND VGND VPWR VPWR sky130_fd_sc_hd__decap_3
XTAP_TAPCELL_ROW_103_1487 VGND VPWR sky130_fd_sc_hd__tapvpwrvgnd_1
X_3620_ _3620_/A _4292_/B _3620_/C VGND VGND VPWR VPWR _3620_/X sky130_fd_sc_hd__or3_4
X_3551_ _3508_/A _3547_/Y _3550_/X VGND VGND VPWR VPWR _3551_/X sky130_fd_sc_hd__a21o_2
XFILLER_115_414 VGND VGND VPWR VPWR sky130_fd_sc_hd__decap_3
XFILLER_115_458 VGND VGND VPWR VPWR sky130_fd_sc_hd__fill_2
XFILLER_51_3 VGND VGND VPWR VPWR sky130_fd_sc_hd__decap_3
X_6270_ _6553_/A VGND VGND VPWR VPWR _6270_/Y sky130_fd_sc_hd__inv_2
X_3482_ _3482_/A _3482_/B _3482_/C VGND VGND VPWR VPWR _3482_/Y sky130_fd_sc_hd__nor3_2
XFILLER_88_309 VGND VGND VPWR VPWR sky130_fd_sc_hd__decap_3
X_5221_ _5221_/A _5225_/B VGND VGND VPWR VPWR _7218_/D sky130_fd_sc_hd__and2_2
XTAP_TAPCELL_ROW_71_1100 VGND VPWR sky130_fd_sc_hd__tapvpwrvgnd_1
XFILLER_111_631 VGND VGND VPWR VPWR sky130_fd_sc_hd__decap_3
XFILLER_69_523 VGND VGND VPWR VPWR sky130_fd_sc_hd__decap_3
X_5152_ _7009_/Q _5152_/B VGND VGND VPWR VPWR _5152_/Y sky130_fd_sc_hd__nand2_2
XFILLER_110_141 VGND VGND VPWR VPWR sky130_fd_sc_hd__decap_3
XFILLER_69_556 VGND VGND VPWR VPWR sky130_fd_sc_hd__decap_3
XFILLER_84_504 VGND VGND VPWR VPWR sky130_fd_sc_hd__decap_3
XFILLER_96_342 VGND VGND VPWR VPWR sky130_fd_sc_hd__decap_3
X_4103_ _7365_/Q _4270_/B _4267_/B1 _7173_/Q VGND VGND VPWR VPWR _4103_/X sky130_fd_sc_hd__a22o_2
XFILLER_56_206 VGND VGND VPWR VPWR sky130_fd_sc_hd__decap_3
XFILLER_96_386 VGND VGND VPWR VPWR sky130_fd_sc_hd__decap_3
X_5083_ _5086_/A _4343_/X VGND VGND VPWR VPWR _5083_/X sky130_fd_sc_hd__or2b_2
XFILLER_110_185 VGND VGND VPWR VPWR sky130_fd_sc_hd__fill_2
XFILLER_37_420 VGND VGND VPWR VPWR sky130_fd_sc_hd__decap_3
XFILLER_84_548 VGND VGND VPWR VPWR sky130_fd_sc_hd__decap_3
X_4034_ _7150_/Q _4434_/B1 _4032_/X _4033_/X VGND VGND VPWR VPWR _4034_/X sky130_fd_sc_hd__a211o_2
XTAP_TAPCELL_ROW_55_908 VGND VPWR sky130_fd_sc_hd__tapvpwrvgnd_1
XFILLER_25_615 VGND VGND VPWR VPWR sky130_fd_sc_hd__fill_1
XFILLER_25_637 VGND VGND VPWR VPWR sky130_fd_sc_hd__decap_3
XTAP_TAPCELL_ROW_69_1084 VGND VPWR sky130_fd_sc_hd__tapvpwrvgnd_1
XFILLER_12_309 VGND VGND VPWR VPWR sky130_fd_sc_hd__decap_3
XFILLER_52_445 VGND VGND VPWR VPWR sky130_fd_sc_hd__decap_3
XTAP_TAPCELL_ROW_82_1240 VGND VPWR sky130_fd_sc_hd__tapvpwrvgnd_1
X_4936_ _4936_/A _4936_/B VGND VGND VPWR VPWR _4936_/Y sky130_fd_sc_hd__xnor2_2
XTAP_TAPCELL_ROW_35_676 VGND VPWR sky130_fd_sc_hd__tapvpwrvgnd_1
XANTENNA_10 _4322_/X VGND VGND VPWR VPWR sky130_fd_sc_hd__diode_2
XANTENNA_21 _7366_/Q VGND VGND VPWR VPWR sky130_fd_sc_hd__diode_2
XANTENNA_32 _5663_/A VGND VGND VPWR VPWR sky130_fd_sc_hd__diode_2
XFILLER_20_342 VGND VGND VPWR VPWR sky130_fd_sc_hd__decap_3
XFILLER_32_191 VGND VGND VPWR VPWR sky130_fd_sc_hd__decap_3
X_4867_ _6998_/Q _4912_/A VGND VGND VPWR VPWR _4882_/A sky130_fd_sc_hd__nand2_2
X_6606_ _6606_/A VGND VGND VPWR VPWR _6606_/Y sky130_fd_sc_hd__inv_2
X_3818_ hold974/X _3818_/A2 _3817_/X VGND VGND VPWR VPWR _7390_/D sky130_fd_sc_hd__o21a_2
XFILLER_20_386 VGND VGND VPWR VPWR sky130_fd_sc_hd__fill_1
X_6537_ _6540_/A VGND VGND VPWR VPWR _6537_/Y sky130_fd_sc_hd__inv_2
X_4798_ _4811_/C _4795_/X _4796_/Y _4797_/X VGND VGND VPWR VPWR _5656_/A sky130_fd_sc_hd__a211o_2
X_3749_ _3726_/X _3734_/X _3748_/X _5151_/A VGND VGND VPWR VPWR _3749_/Y sky130_fd_sc_hd__o31ai_2
XFILLER_106_436 VGND VGND VPWR VPWR sky130_fd_sc_hd__decap_3
XFILLER_97_18 VGND VGND VPWR VPWR sky130_fd_sc_hd__decap_3
X_6468_ _6539_/A VGND VGND VPWR VPWR _6468_/Y sky130_fd_sc_hd__inv_2
XFILLER_79_309 VGND VGND VPWR VPWR sky130_fd_sc_hd__decap_3
X_6399_ _6562_/A VGND VGND VPWR VPWR _6399_/Y sky130_fd_sc_hd__inv_2
X_5419_ _5419_/A0 _5131_/X _5419_/S VGND VGND VPWR VPWR _7124_/D sky130_fd_sc_hd__mux2_2
XFILLER_87_320 VGND VGND VPWR VPWR sky130_fd_sc_hd__decap_3
XTAP_TAPCELL_ROW_7_335 VGND VPWR sky130_fd_sc_hd__tapvpwrvgnd_1
XFILLER_87_364 VGND VGND VPWR VPWR sky130_fd_sc_hd__decap_3
XFILLER_47_228 VGND VGND VPWR VPWR sky130_fd_sc_hd__decap_3
XFILLER_75_537 VGND VGND VPWR VPWR sky130_fd_sc_hd__decap_3
XFILLER_46_55 VGND VGND VPWR VPWR sky130_fd_sc_hd__decap_3
XFILLER_55_261 VGND VGND VPWR VPWR sky130_fd_sc_hd__decap_3
XFILLER_83_570 VGND VGND VPWR VPWR sky130_fd_sc_hd__decap_3
XFILLER_15_103 VGND VGND VPWR VPWR sky130_fd_sc_hd__decap_3
XFILLER_43_434 VGND VGND VPWR VPWR sky130_fd_sc_hd__fill_1
XFILLER_46_88 VGND VGND VPWR VPWR sky130_fd_sc_hd__fill_2
XFILLER_70_220 VGND VGND VPWR VPWR sky130_fd_sc_hd__decap_3
XFILLER_15_169 VGND VGND VPWR VPWR sky130_fd_sc_hd__decap_3
XFILLER_43_467 VGND VGND VPWR VPWR sky130_fd_sc_hd__fill_2
XFILLER_62_21 VGND VGND VPWR VPWR sky130_fd_sc_hd__decap_3
XFILLER_70_253 VGND VGND VPWR VPWR sky130_fd_sc_hd__decap_3
XFILLER_102_83 VGND VGND VPWR VPWR sky130_fd_sc_hd__fill_1
XFILLER_30_117 VGND VGND VPWR VPWR sky130_fd_sc_hd__decap_3
XFILLER_62_32 VGND VGND VPWR VPWR sky130_fd_sc_hd__decap_3
XFILLER_62_76 VGND VGND VPWR VPWR sky130_fd_sc_hd__decap_3
XFILLER_70_297 VGND VGND VPWR VPWR sky130_fd_sc_hd__decap_3
XFILLER_11_364 VGND VGND VPWR VPWR sky130_fd_sc_hd__decap_3
XFILLER_7_302 VGND VGND VPWR VPWR sky130_fd_sc_hd__decap_3
XFILLER_7_346 VGND VGND VPWR VPWR sky130_fd_sc_hd__decap_3
XTAP_TAPCELL_ROW_96_1409 VGND VPWR sky130_fd_sc_hd__tapvpwrvgnd_1
XFILLER_109_252 VGND VGND VPWR VPWR sky130_fd_sc_hd__decap_3
XFILLER_7_379 VGND VGND VPWR VPWR sky130_fd_sc_hd__fill_2
XFILLER_109_296 VGND VGND VPWR VPWR sky130_fd_sc_hd__fill_2
XFILLER_97_106 VGND VGND VPWR VPWR sky130_fd_sc_hd__decap_3
XFILLER_98_629 VGND VGND VPWR VPWR sky130_fd_sc_hd__fill_1
XFILLER_97_128 VGND VGND VPWR VPWR sky130_fd_sc_hd__fill_2
XFILLER_105_491 VGND VGND VPWR VPWR sky130_fd_sc_hd__fill_1
XFILLER_87_84 VGND VGND VPWR VPWR sky130_fd_sc_hd__decap_3
XFILLER_66_504 VGND VGND VPWR VPWR sky130_fd_sc_hd__decap_3
XFILLER_78_386 VGND VGND VPWR VPWR sky130_fd_sc_hd__decap_3
XFILLER_93_301 VGND VGND VPWR VPWR sky130_fd_sc_hd__decap_3
XFILLER_16_6 VGND VGND VPWR VPWR sky130_fd_sc_hd__decap_3
XFILLER_19_420 VGND VGND VPWR VPWR sky130_fd_sc_hd__decap_3
XFILLER_38_239 VGND VGND VPWR VPWR sky130_fd_sc_hd__decap_3
XFILLER_66_548 VGND VGND VPWR VPWR sky130_fd_sc_hd__decap_3
XFILLER_93_334 VGND VGND VPWR VPWR sky130_fd_sc_hd__fill_2
XFILLER_81_529 VGND VGND VPWR VPWR sky130_fd_sc_hd__decap_3
XFILLER_93_367 VGND VGND VPWR VPWR sky130_fd_sc_hd__decap_3
XFILLER_74_581 VGND VGND VPWR VPWR sky130_fd_sc_hd__decap_3
XFILLER_74_592 VGND VGND VPWR VPWR sky130_fd_sc_hd__decap_3
XTAP_TAPCELL_ROW_105_1516 VGND VPWR sky130_fd_sc_hd__tapvpwrvgnd_1
XFILLER_61_231 VGND VGND VPWR VPWR sky130_fd_sc_hd__decap_3
XFILLER_61_253 VGND VGND VPWR VPWR sky130_fd_sc_hd__decap_3
XFILLER_22_618 VGND VGND VPWR VPWR sky130_fd_sc_hd__fill_1
XFILLER_99_3 VGND VGND VPWR VPWR sky130_fd_sc_hd__decap_3
XFILLER_14_180 VGND VGND VPWR VPWR sky130_fd_sc_hd__fill_2
XFILLER_21_139 VGND VGND VPWR VPWR sky130_fd_sc_hd__decap_3
X_4721_ _3534_/Y _4658_/A _4055_/A VGND VGND VPWR VPWR _4721_/Y sky130_fd_sc_hd__a21oi_2
XTAP_TAPCELL_ROW_60_966 VGND VPWR sky130_fd_sc_hd__tapvpwrvgnd_1
XTAP_TAPCELL_ROW_32_635 VGND VPWR sky130_fd_sc_hd__tapvpwrvgnd_1
X_4652_ _4652_/A _4652_/B VGND VGND VPWR VPWR _4785_/A sky130_fd_sc_hd__nor2_2
XTAP_TAPCELL_ROW_60_977 VGND VPWR sky130_fd_sc_hd__tapvpwrvgnd_1
X_3603_ _4614_/B _3603_/B VGND VGND VPWR VPWR _3603_/Y sky130_fd_sc_hd__nand2_2
X_7371_ _7371_/CLK _7371_/D _6651_/Y VGND VGND VPWR VPWR _7371_/Q sky130_fd_sc_hd__dfrtp_2
Xhold803 _6852_/Q VGND VGND VPWR VPWR _6852_/D sky130_fd_sc_hd__dlygate4sd3_1
X_4583_ _4583_/A _4583_/B VGND VGND VPWR VPWR _7289_/D sky130_fd_sc_hd__and2_2
XTAP_TAPCELL_ROW_12_392 VGND VPWR sky130_fd_sc_hd__tapvpwrvgnd_1
Xhold814 _6949_/Q VGND VGND VPWR VPWR _6949_/D sky130_fd_sc_hd__dlygate4sd3_1
Xhold825 _6809_/Q VGND VGND VPWR VPWR _6809_/D sky130_fd_sc_hd__dlygate4sd3_1
Xhold836 _6974_/Q VGND VGND VPWR VPWR _6974_/D sky130_fd_sc_hd__dlygate4sd3_1
X_6322_ _6644_/A VGND VGND VPWR VPWR _6322_/Y sky130_fd_sc_hd__inv_2
X_3534_ _3509_/Y _3510_/X _4419_/B1 VGND VGND VPWR VPWR _3534_/Y sky130_fd_sc_hd__a21oi_2
XTAP_TAPCELL_ROW_116_1656 VGND VPWR sky130_fd_sc_hd__tapvpwrvgnd_1
XTAP_TAPCELL_ROW_116_1645 VGND VPWR sky130_fd_sc_hd__tapvpwrvgnd_1
Xhold847 _7068_/Q VGND VGND VPWR VPWR _7068_/D sky130_fd_sc_hd__dlygate4sd3_1
Xhold858 _7069_/Q VGND VGND VPWR VPWR _7069_/D sky130_fd_sc_hd__dlygate4sd3_1
Xhold869 _7082_/Q VGND VGND VPWR VPWR _7082_/D sky130_fd_sc_hd__dlygate4sd3_1
Xmax_cap566 _4291_/A VGND VGND VPWR VPWR _4612_/A sky130_fd_sc_hd__clkbuf_2
X_3465_ _7185_/Q _3994_/S _4332_/B1 _7377_/Q VGND VGND VPWR VPWR _3465_/X sky130_fd_sc_hd__a22o_2
XFILLER_115_288 VGND VGND VPWR VPWR sky130_fd_sc_hd__fill_2
XFILLER_88_117 VGND VGND VPWR VPWR sky130_fd_sc_hd__decap_3
XFILLER_69_331 VGND VGND VPWR VPWR sky130_fd_sc_hd__decap_3
XTAP_TAPCELL_ROW_4_305 VGND VPWR sky130_fd_sc_hd__tapvpwrvgnd_1
XFILLER_29_217 VGND VGND VPWR VPWR sky130_fd_sc_hd__decap_3
XFILLER_69_375 VGND VGND VPWR VPWR sky130_fd_sc_hd__decap_3
XFILLER_84_312 VGND VGND VPWR VPWR sky130_fd_sc_hd__decap_3
XFILLER_96_150 VGND VGND VPWR VPWR sky130_fd_sc_hd__decap_3
X_5135_ _3371_/A _5666_/A _4664_/A _5134_/X VGND VGND VPWR VPWR _5135_/X sky130_fd_sc_hd__a211o_2
XFILLER_29_228 VGND VGND VPWR VPWR sky130_fd_sc_hd__decap_3
XFILLER_57_559 VGND VGND VPWR VPWR sky130_fd_sc_hd__fill_1
XFILLER_84_323 VGND VGND VPWR VPWR sky130_fd_sc_hd__decap_3
XFILLER_96_183 VGND VGND VPWR VPWR sky130_fd_sc_hd__decap_3
X_5066_ _5066_/A _5066_/B VGND VGND VPWR VPWR _6987_/D sky130_fd_sc_hd__nor2_2
XFILLER_44_209 VGND VGND VPWR VPWR sky130_fd_sc_hd__decap_3
XFILLER_72_529 VGND VGND VPWR VPWR sky130_fd_sc_hd__decap_3
XFILLER_84_389 VGND VGND VPWR VPWR sky130_fd_sc_hd__decap_3
X_4017_ _7310_/Q _4491_/S _4430_/B1 _7182_/Q VGND VGND VPWR VPWR _4017_/X sky130_fd_sc_hd__a22o_2
XFILLER_37_272 VGND VGND VPWR VPWR sky130_fd_sc_hd__decap_3
XFILLER_65_581 VGND VGND VPWR VPWR sky130_fd_sc_hd__fill_2
XFILLER_16_69 VGND VGND VPWR VPWR sky130_fd_sc_hd__decap_3
XFILLER_25_467 VGND VGND VPWR VPWR sky130_fd_sc_hd__decap_3
XFILLER_52_253 VGND VGND VPWR VPWR sky130_fd_sc_hd__decap_3
XFILLER_80_551 VGND VGND VPWR VPWR sky130_fd_sc_hd__decap_3
XFILLER_52_286 VGND VGND VPWR VPWR sky130_fd_sc_hd__fill_2
XFILLER_80_584 VGND VGND VPWR VPWR sky130_fd_sc_hd__decap_3
XFILLER_80_595 VGND VGND VPWR VPWR sky130_fd_sc_hd__decap_3
X_4919_ _4937_/A _4936_/B _4938_/B VGND VGND VPWR VPWR _4920_/B sky130_fd_sc_hd__o21ba_2
XFILLER_21_673 VGND VGND VPWR VPWR sky130_fd_sc_hd__fill_2
XFILLER_32_57 VGND VGND VPWR VPWR sky130_fd_sc_hd__fill_1
XFILLER_32_79 VGND VGND VPWR VPWR sky130_fd_sc_hd__decap_3
XFILLER_20_194 VGND VGND VPWR VPWR sky130_fd_sc_hd__fill_2
XFILLER_106_200 VGND VGND VPWR VPWR sky130_fd_sc_hd__decap_3
XFILLER_4_327 VGND VGND VPWR VPWR sky130_fd_sc_hd__decap_3
XFILLER_106_288 VGND VGND VPWR VPWR sky130_fd_sc_hd__decap_3
XTAP_TAPCELL_ROW_91_1339 VGND VPWR sky130_fd_sc_hd__tapvpwrvgnd_1
XFILLER_88_640 VGND VGND VPWR VPWR sky130_fd_sc_hd__decap_3
XFILLER_88_662 VGND VGND VPWR VPWR sky130_fd_sc_hd__decap_3
XFILLER_102_461 VGND VGND VPWR VPWR sky130_fd_sc_hd__decap_3
XFILLER_57_21 VGND VGND VPWR VPWR sky130_fd_sc_hd__decap_3
XFILLER_75_312 VGND VGND VPWR VPWR sky130_fd_sc_hd__fill_1
XFILLER_102_483 VGND VGND VPWR VPWR sky130_fd_sc_hd__fill_2
XFILLER_57_54 VGND VGND VPWR VPWR sky130_fd_sc_hd__fill_2
XFILLER_87_194 VGND VGND VPWR VPWR sky130_fd_sc_hd__decap_3
XFILLER_75_367 VGND VGND VPWR VPWR sky130_fd_sc_hd__decap_3
XFILLER_90_304 VGND VGND VPWR VPWR sky130_fd_sc_hd__decap_3
XFILLER_113_60 VGND VGND VPWR VPWR sky130_fd_sc_hd__decap_3
XFILLER_73_31 VGND VGND VPWR VPWR sky130_fd_sc_hd__decap_3
XFILLER_75_389 VGND VGND VPWR VPWR sky130_fd_sc_hd__decap_3
XFILLER_90_315 VGND VGND VPWR VPWR sky130_fd_sc_hd__decap_3
XFILLER_90_348 VGND VGND VPWR VPWR sky130_fd_sc_hd__decap_3
XFILLER_113_93 VGND VGND VPWR VPWR sky130_fd_sc_hd__decap_3
XFILLER_16_445 VGND VGND VPWR VPWR sky130_fd_sc_hd__decap_3
XFILLER_16_467 VGND VGND VPWR VPWR sky130_fd_sc_hd__decap_3
XFILLER_71_540 VGND VGND VPWR VPWR sky130_fd_sc_hd__decap_3
XFILLER_16_489 VGND VGND VPWR VPWR sky130_fd_sc_hd__fill_1
XFILLER_43_275 VGND VGND VPWR VPWR sky130_fd_sc_hd__decap_3
XFILLER_71_573 VGND VGND VPWR VPWR sky130_fd_sc_hd__decap_3
XFILLER_71_595 VGND VGND VPWR VPWR sky130_fd_sc_hd__fill_2
XFILLER_31_437 VGND VGND VPWR VPWR sky130_fd_sc_hd__fill_1
XTAP_TAPCELL_ROW_100_1457 VGND VPWR sky130_fd_sc_hd__tapvpwrvgnd_1
XTAP_TAPCELL_ROW_100_1446 VGND VPWR sky130_fd_sc_hd__tapvpwrvgnd_1
XFILLER_11_161 VGND VGND VPWR VPWR sky130_fd_sc_hd__decap_3
XFILLER_11_172 VGND VGND VPWR VPWR sky130_fd_sc_hd__decap_3
XFILLER_7_110 VGND VGND VPWR VPWR sky130_fd_sc_hd__fill_2
XFILLER_7_154 VGND VGND VPWR VPWR sky130_fd_sc_hd__decap_3
XFILLER_7_187 VGND VGND VPWR VPWR sky130_fd_sc_hd__decap_3
XFILLER_112_203 VGND VGND VPWR VPWR sky130_fd_sc_hd__decap_3
XFILLER_98_72 VGND VGND VPWR VPWR sky130_fd_sc_hd__decap_3
XFILLER_98_415 VGND VGND VPWR VPWR sky130_fd_sc_hd__decap_3
XFILLER_3_393 VGND VGND VPWR VPWR sky130_fd_sc_hd__decap_3
XFILLER_66_301 VGND VGND VPWR VPWR sky130_fd_sc_hd__decap_3
XFILLER_66_312 VGND VGND VPWR VPWR sky130_fd_sc_hd__fill_2
XFILLER_78_161 VGND VGND VPWR VPWR sky130_fd_sc_hd__decap_3
XFILLER_79_673 VGND VGND VPWR VPWR sky130_fd_sc_hd__fill_2
XFILLER_94_621 VGND VGND VPWR VPWR sky130_fd_sc_hd__decap_3
XTAP_TAPCELL_ROW_111_1586 VGND VPWR sky130_fd_sc_hd__tapvpwrvgnd_1
XFILLER_14_3 VGND VGND VPWR VPWR sky130_fd_sc_hd__decap_3
XFILLER_78_194 VGND VGND VPWR VPWR sky130_fd_sc_hd__fill_2
XFILLER_94_654 VGND VGND VPWR VPWR sky130_fd_sc_hd__decap_3
XFILLER_26_209 VGND VGND VPWR VPWR sky130_fd_sc_hd__decap_3
XFILLER_54_518 VGND VGND VPWR VPWR sky130_fd_sc_hd__decap_3
XFILLER_66_356 VGND VGND VPWR VPWR sky130_fd_sc_hd__decap_3
XFILLER_93_164 VGND VGND VPWR VPWR sky130_fd_sc_hd__decap_3
X_6940_ _7404_/CLK _6940_/D VGND VGND VPWR VPWR _6940_/Q sky130_fd_sc_hd__dfxtp_2
XFILLER_19_261 VGND VGND VPWR VPWR sky130_fd_sc_hd__decap_3
XFILLER_81_315 VGND VGND VPWR VPWR sky130_fd_sc_hd__decap_3
XFILLER_81_326 VGND VGND VPWR VPWR sky130_fd_sc_hd__decap_3
XFILLER_81_337 VGND VGND VPWR VPWR sky130_fd_sc_hd__decap_3
XFILLER_93_175 VGND VGND VPWR VPWR sky130_fd_sc_hd__decap_3
X_6871_ _7384_/CLK _6871_/D VGND VGND VPWR VPWR _6871_/Q sky130_fd_sc_hd__dfxtp_2
XTAP_TAPCELL_ROW_66_1043 VGND VPWR sky130_fd_sc_hd__tapvpwrvgnd_1
XFILLER_22_404 VGND VGND VPWR VPWR sky130_fd_sc_hd__decap_3
XFILLER_62_562 VGND VGND VPWR VPWR sky130_fd_sc_hd__decap_3
XTAP_TAPCELL_ROW_17_451 VGND VPWR sky130_fd_sc_hd__tapvpwrvgnd_1
XFILLER_34_286 VGND VGND VPWR VPWR sky130_fd_sc_hd__decap_3
XFILLER_62_595 VGND VGND VPWR VPWR sky130_fd_sc_hd__decap_3
XTAP_TAPCELL_ROW_45_793 VGND VPWR sky130_fd_sc_hd__tapvpwrvgnd_1
X_4704_ _6994_/Q _4977_/A VGND VGND VPWR VPWR _4963_/A sky130_fd_sc_hd__and2_2
XFILLER_30_492 VGND VGND VPWR VPWR sky130_fd_sc_hd__decap_3
X_5684_ _7348_/Q hold967/X _5708_/S VGND VGND VPWR VPWR _6692_/D sky130_fd_sc_hd__mux2_2
X_4635_ _4916_/A _4916_/B _4633_/X _4634_/Y VGND VGND VPWR VPWR _4646_/A sky130_fd_sc_hd__a211o_2
XFILLER_116_531 VGND VGND VPWR VPWR sky130_fd_sc_hd__fill_1
X_7354_ _7381_/CLK _7354_/D _6634_/Y VGND VGND VPWR VPWR _7354_/Q sky130_fd_sc_hd__dfrtp_2
Xhold600 _6867_/Q VGND VGND VPWR VPWR _6867_/D sky130_fd_sc_hd__dlygate4sd3_1
Xhold611 _6865_/Q VGND VGND VPWR VPWR _6865_/D sky130_fd_sc_hd__dlygate4sd3_1
XFILLER_116_542 VGND VGND VPWR VPWR sky130_fd_sc_hd__decap_3
XFILLER_116_564 VGND VGND VPWR VPWR sky130_fd_sc_hd__fill_2
Xhold622 _6973_/Q VGND VGND VPWR VPWR _6973_/D sky130_fd_sc_hd__dlygate4sd3_1
Xhold633 _6804_/Q VGND VGND VPWR VPWR _6804_/D sky130_fd_sc_hd__dlygate4sd3_1
Xhold644 _6853_/Q VGND VGND VPWR VPWR _6853_/D sky130_fd_sc_hd__dlygate4sd3_1
X_6305_ _6647_/A VGND VGND VPWR VPWR _6305_/Y sky130_fd_sc_hd__inv_2
X_3517_ _3386_/B _3370_/Y _3516_/X VGND VGND VPWR VPWR _3525_/A sky130_fd_sc_hd__a21bo_2
XTAP_TAPCELL_ROW_77_1172 VGND VPWR sky130_fd_sc_hd__tapvpwrvgnd_1
XFILLER_103_214 VGND VGND VPWR VPWR sky130_fd_sc_hd__decap_3
XFILLER_103_225 VGND VGND VPWR VPWR sky130_fd_sc_hd__decap_3
XFILLER_89_426 VGND VGND VPWR VPWR sky130_fd_sc_hd__decap_3
X_7285_ clkload2/A _7285_/D _6565_/Y VGND VGND VPWR VPWR _7285_/Q sky130_fd_sc_hd__dfrtp_2
Xhold655 _6829_/Q VGND VGND VPWR VPWR _6829_/D sky130_fd_sc_hd__dlygate4sd3_1
Xhold666 _6965_/Q VGND VGND VPWR VPWR _6965_/D sky130_fd_sc_hd__dlygate4sd3_1
Xhold677 _6759_/Q VGND VGND VPWR VPWR _6759_/D sky130_fd_sc_hd__dlygate4sd3_1
Xhold688 _6839_/Q VGND VGND VPWR VPWR _6839_/D sky130_fd_sc_hd__dlygate4sd3_1
X_4497_ _4497_/A0 _7299_/Q _4501_/S VGND VGND VPWR VPWR _7331_/D sky130_fd_sc_hd__mux2_2
Xhold699 _6815_/Q VGND VGND VPWR VPWR _6815_/D sky130_fd_sc_hd__dlygate4sd3_1
X_3448_ _7282_/Q _5159_/S _4334_/B1 _7154_/Q _3447_/X VGND VGND VPWR VPWR _3448_/X
+ sky130_fd_sc_hd__a221o_2
XFILLER_69_161 VGND VGND VPWR VPWR sky130_fd_sc_hd__fill_1
XFILLER_85_610 VGND VGND VPWR VPWR sky130_fd_sc_hd__decap_3
XFILLER_97_470 VGND VGND VPWR VPWR sky130_fd_sc_hd__decap_3
X_3379_ _7219_/Q _4340_/A2 _4246_/B1 _7123_/Q VGND VGND VPWR VPWR _3379_/X sky130_fd_sc_hd__a22o_2
XFILLER_111_291 VGND VGND VPWR VPWR sky130_fd_sc_hd__fill_1
XFILLER_57_323 VGND VGND VPWR VPWR sky130_fd_sc_hd__decap_3
XFILLER_69_172 VGND VGND VPWR VPWR sky130_fd_sc_hd__decap_3
XFILLER_85_643 VGND VGND VPWR VPWR sky130_fd_sc_hd__decap_3
X_5118_ _5118_/A _6984_/Q _5118_/C _5118_/D VGND VGND VPWR VPWR _5118_/X sky130_fd_sc_hd__or4_2
XFILLER_57_367 VGND VGND VPWR VPWR sky130_fd_sc_hd__decap_3
XFILLER_72_304 VGND VGND VPWR VPWR sky130_fd_sc_hd__decap_3
XFILLER_84_153 VGND VGND VPWR VPWR sky130_fd_sc_hd__fill_2
XFILLER_84_164 VGND VGND VPWR VPWR sky130_fd_sc_hd__fill_2
XFILLER_85_665 VGND VGND VPWR VPWR sky130_fd_sc_hd__fill_1
XFILLER_85_676 VGND VGND VPWR VPWR sky130_fd_sc_hd__decap_3
XFILLER_27_57 VGND VGND VPWR VPWR sky130_fd_sc_hd__decap_3
XFILLER_84_197 VGND VGND VPWR VPWR sky130_fd_sc_hd__fill_2
X_5049_ _5072_/B _5073_/B _5071_/B VGND VGND VPWR VPWR _5049_/X sky130_fd_sc_hd__a21bo_2
XFILLER_25_220 VGND VGND VPWR VPWR sky130_fd_sc_hd__decap_3
XFILLER_25_242 VGND VGND VPWR VPWR sky130_fd_sc_hd__decap_3
XFILLER_72_348 VGND VGND VPWR VPWR sky130_fd_sc_hd__fill_1
XFILLER_25_275 VGND VGND VPWR VPWR sky130_fd_sc_hd__decap_3
XFILLER_43_23 VGND VGND VPWR VPWR sky130_fd_sc_hd__decap_3
XFILLER_40_223 VGND VGND VPWR VPWR sky130_fd_sc_hd__decap_3
XFILLER_40_256 VGND VGND VPWR VPWR sky130_fd_sc_hd__decap_3
XFILLER_43_89 VGND VGND VPWR VPWR sky130_fd_sc_hd__decap_3
XFILLER_5_614 VGND VGND VPWR VPWR sky130_fd_sc_hd__fill_2
XFILLER_107_531 VGND VGND VPWR VPWR sky130_fd_sc_hd__decap_3
XFILLER_107_564 VGND VGND VPWR VPWR sky130_fd_sc_hd__fill_2
XFILLER_4_135 VGND VGND VPWR VPWR sky130_fd_sc_hd__decap_3
XFILLER_4_179 VGND VGND VPWR VPWR sky130_fd_sc_hd__decap_3
XFILLER_4_39 VGND VGND VPWR VPWR sky130_fd_sc_hd__decap_3
XFILLER_0_330 VGND VGND VPWR VPWR sky130_fd_sc_hd__decap_3
XFILLER_68_53 VGND VGND VPWR VPWR sky130_fd_sc_hd__decap_3
XFILLER_0_396 VGND VGND VPWR VPWR sky130_fd_sc_hd__decap_3
XFILLER_48_312 VGND VGND VPWR VPWR sky130_fd_sc_hd__decap_3
XFILLER_68_97 VGND VGND VPWR VPWR sky130_fd_sc_hd__decap_3
XFILLER_88_492 VGND VGND VPWR VPWR sky130_fd_sc_hd__decap_3
XFILLER_102_291 VGND VGND VPWR VPWR sky130_fd_sc_hd__decap_3
XFILLER_48_345 VGND VGND VPWR VPWR sky130_fd_sc_hd__decap_3
XFILLER_75_142 VGND VGND VPWR VPWR sky130_fd_sc_hd__decap_3
XFILLER_63_326 VGND VGND VPWR VPWR sky130_fd_sc_hd__decap_3
XFILLER_63_337 VGND VGND VPWR VPWR sky130_fd_sc_hd__decap_3
XFILLER_75_175 VGND VGND VPWR VPWR sky130_fd_sc_hd__decap_3
XFILLER_90_112 VGND VGND VPWR VPWR sky130_fd_sc_hd__decap_3
Xplace304 _4361_/A VGND VGND VPWR VPWR _5086_/A sky130_fd_sc_hd__buf_2
XFILLER_16_242 VGND VGND VPWR VPWR sky130_fd_sc_hd__decap_3
XFILLER_84_85 VGND VGND VPWR VPWR sky130_fd_sc_hd__decap_3
XFILLER_90_134 VGND VGND VPWR VPWR sky130_fd_sc_hd__decap_3
Xplace337 _4262_/A2 VGND VGND VPWR VPWR _4349_/B1 sky130_fd_sc_hd__buf_2
Xplace326 _4460_/A VGND VGND VPWR VPWR _4205_/A sky130_fd_sc_hd__buf_2
Xplace315 _5274_/S VGND VGND VPWR VPWR _5262_/S sky130_fd_sc_hd__buf_2
XFILLER_16_253 VGND VGND VPWR VPWR sky130_fd_sc_hd__decap_3
XFILLER_90_178 VGND VGND VPWR VPWR sky130_fd_sc_hd__decap_3
Xplace359 _5080_/S VGND VGND VPWR VPWR _4417_/A2 sky130_fd_sc_hd__buf_2
Xplace348 _4270_/B VGND VGND VPWR VPWR _4394_/B sky130_fd_sc_hd__buf_2
XFILLER_16_286 VGND VGND VPWR VPWR sky130_fd_sc_hd__decap_3
XFILLER_31_212 VGND VGND VPWR VPWR sky130_fd_sc_hd__decap_3
XTAP_TAPCELL_ROW_14_421 VGND VPWR sky130_fd_sc_hd__tapvpwrvgnd_1
XFILLER_31_245 VGND VGND VPWR VPWR sky130_fd_sc_hd__decap_3
XTAP_TAPCELL_ROW_42_752 VGND VPWR sky130_fd_sc_hd__tapvpwrvgnd_1
X_4420_ _7336_/Q _3945_/S _5229_/C _7144_/Q VGND VGND VPWR VPWR _4420_/X sky130_fd_sc_hd__a22o_2
XTAP_TAPCELL_ROW_113_1604 VGND VPWR sky130_fd_sc_hd__tapvpwrvgnd_1
XFILLER_113_523 VGND VGND VPWR VPWR sky130_fd_sc_hd__decap_3
X_4351_ _7097_/Q _4351_/A2 _4351_/B1 _7129_/Q VGND VGND VPWR VPWR _4351_/X sky130_fd_sc_hd__a22o_2
X_7070_ _7364_/CLK _7070_/D _6350_/Y VGND VGND VPWR VPWR _7070_/Q sky130_fd_sc_hd__dfrtp_2
X_4282_ _7062_/Q _3577_/B _3590_/A _4281_/X VGND VGND VPWR VPWR _4291_/A sky130_fd_sc_hd__o211ai_2
X_3302_ _3353_/A _6979_/Q _6981_/Q VGND VGND VPWR VPWR _3302_/X sky130_fd_sc_hd__a21o_2
XFILLER_100_206 VGND VGND VPWR VPWR sky130_fd_sc_hd__fill_2
XFILLER_79_470 VGND VGND VPWR VPWR sky130_fd_sc_hd__decap_3
XFILLER_86_407 VGND VGND VPWR VPWR sky130_fd_sc_hd__decap_3
XFILLER_100_228 VGND VGND VPWR VPWR sky130_fd_sc_hd__decap_3
XFILLER_104_18 VGND VGND VPWR VPWR sky130_fd_sc_hd__decap_3
XFILLER_39_334 VGND VGND VPWR VPWR sky130_fd_sc_hd__fill_2
XFILLER_67_643 VGND VGND VPWR VPWR sky130_fd_sc_hd__decap_3
XFILLER_104_29 VGND VGND VPWR VPWR sky130_fd_sc_hd__decap_3
XFILLER_66_131 VGND VGND VPWR VPWR sky130_fd_sc_hd__decap_3
XFILLER_66_153 VGND VGND VPWR VPWR sky130_fd_sc_hd__decap_3
XFILLER_39_378 VGND VGND VPWR VPWR sky130_fd_sc_hd__decap_3
XFILLER_54_326 VGND VGND VPWR VPWR sky130_fd_sc_hd__decap_3
XFILLER_82_624 VGND VGND VPWR VPWR sky130_fd_sc_hd__decap_3
XFILLER_82_635 VGND VGND VPWR VPWR sky130_fd_sc_hd__decap_3
XFILLER_94_473 VGND VGND VPWR VPWR sky130_fd_sc_hd__decap_3
XFILLER_54_359 VGND VGND VPWR VPWR sky130_fd_sc_hd__decap_3
XFILLER_66_197 VGND VGND VPWR VPWR sky130_fd_sc_hd__decap_3
XFILLER_81_134 VGND VGND VPWR VPWR sky130_fd_sc_hd__fill_2
X_6923_ _6936_/CLK _6923_/D VGND VGND VPWR VPWR _6923_/Q sky130_fd_sc_hd__dfxtp_2
XFILLER_81_178 VGND VGND VPWR VPWR sky130_fd_sc_hd__decap_3
XFILLER_22_212 VGND VGND VPWR VPWR sky130_fd_sc_hd__decap_3
Xfanout16 _6347_/A VGND VGND VPWR VPWR _6568_/A sky130_fd_sc_hd__buf_2
Xfanout27 _6664_/A VGND VGND VPWR VPWR _6634_/A sky130_fd_sc_hd__buf_2
Xfanout38 _6536_/A VGND VGND VPWR VPWR fanout38/X sky130_fd_sc_hd__clkdlybuf4s25_1
X_6854_ _6968_/CLK _6854_/D VGND VGND VPWR VPWR _6854_/Q sky130_fd_sc_hd__dfxtp_2
XFILLER_22_245 VGND VGND VPWR VPWR sky130_fd_sc_hd__decap_3
XFILLER_22_256 VGND VGND VPWR VPWR sky130_fd_sc_hd__decap_3
Xfanout49 wire582/X VGND VGND VPWR VPWR _6366_/A sky130_fd_sc_hd__buf_2
X_6785_ _6936_/CLK _6785_/D VGND VGND VPWR VPWR _6785_/Q sky130_fd_sc_hd__dfxtp_2
X_5667_ _6979_/Q _5668_/B VGND VGND VPWR VPWR _6979_/D sky130_fd_sc_hd__nor2_2
XTAP_TAPCELL_ROW_79_1201 VGND VPWR sky130_fd_sc_hd__tapvpwrvgnd_1
XFILLER_108_339 VGND VGND VPWR VPWR sky130_fd_sc_hd__decap_3
X_7406_ _7406_/CLK _7406_/D _6686_/Y VGND VGND VPWR VPWR _7406_/Q sky130_fd_sc_hd__dfrtp_2
X_5598_ hold949/X _5587_/B _4468_/X VGND VGND VPWR VPWR _7028_/D sky130_fd_sc_hd__a21o_2
XFILLER_104_523 VGND VGND VPWR VPWR sky130_fd_sc_hd__decap_3
XFILLER_116_350 VGND VGND VPWR VPWR sky130_fd_sc_hd__decap_3
X_7337_ _7338_/CLK _7337_/D _6617_/Y VGND VGND VPWR VPWR _7337_/Q sky130_fd_sc_hd__dfrtp_2
XFILLER_104_556 VGND VGND VPWR VPWR sky130_fd_sc_hd__fill_2
XFILLER_89_234 VGND VGND VPWR VPWR sky130_fd_sc_hd__decap_3
X_7268_ _7361_/CLK _7268_/D _6548_/Y VGND VGND VPWR VPWR _7268_/Q sky130_fd_sc_hd__dfrtp_2
XFILLER_104_578 VGND VGND VPWR VPWR sky130_fd_sc_hd__fill_1
XFILLER_104_589 VGND VGND VPWR VPWR sky130_fd_sc_hd__decap_3
XFILLER_38_12 VGND VGND VPWR VPWR sky130_fd_sc_hd__decap_3
XFILLER_77_429 VGND VGND VPWR VPWR sky130_fd_sc_hd__decap_3
XFILLER_58_643 VGND VGND VPWR VPWR sky130_fd_sc_hd__fill_1
X_7199_ _7359_/CLK _7199_/D _6479_/Y VGND VGND VPWR VPWR _7199_/Q sky130_fd_sc_hd__dfrtp_2
XFILLER_57_131 VGND VGND VPWR VPWR sky130_fd_sc_hd__decap_3
XFILLER_57_153 VGND VGND VPWR VPWR sky130_fd_sc_hd__decap_3
XFILLER_58_654 VGND VGND VPWR VPWR sky130_fd_sc_hd__decap_3
Xhold1130 _7215_/Q VGND VGND VPWR VPWR _5227_/A1 sky130_fd_sc_hd__dlygate4sd3_1
Xhold1141 _7246_/Q VGND VGND VPWR VPWR _5163_/A sky130_fd_sc_hd__dlygate4sd3_1
XFILLER_57_186 VGND VGND VPWR VPWR sky130_fd_sc_hd__decap_3
XFILLER_85_495 VGND VGND VPWR VPWR sky130_fd_sc_hd__decap_3
Xhold1152 _7235_/Q VGND VGND VPWR VPWR _5186_/A sky130_fd_sc_hd__dlygate4sd3_1
Xhold1163 _7140_/Q VGND VGND VPWR VPWR _5386_/A0 sky130_fd_sc_hd__dlygate4sd3_1
Xhold1174 _7146_/Q VGND VGND VPWR VPWR _5373_/A0 sky130_fd_sc_hd__dlygate4sd3_1
Xhold1185 _7153_/Q VGND VGND VPWR VPWR _5356_/A0 sky130_fd_sc_hd__dlygate4sd3_1
XFILLER_72_134 VGND VGND VPWR VPWR sky130_fd_sc_hd__decap_3
Xhold1196 _7120_/Q VGND VGND VPWR VPWR _5427_/A0 sky130_fd_sc_hd__dlygate4sd3_1
XFILLER_54_44 VGND VGND VPWR VPWR sky130_fd_sc_hd__decap_3
XFILLER_54_66 VGND VGND VPWR VPWR sky130_fd_sc_hd__fill_2
XFILLER_60_307 VGND VGND VPWR VPWR sky130_fd_sc_hd__fill_1
XFILLER_72_156 VGND VGND VPWR VPWR sky130_fd_sc_hd__fill_2
XFILLER_13_223 VGND VGND VPWR VPWR sky130_fd_sc_hd__fill_1
XFILLER_13_234 VGND VGND VPWR VPWR sky130_fd_sc_hd__decap_3
XFILLER_53_370 VGND VGND VPWR VPWR sky130_fd_sc_hd__decap_3
XFILLER_110_61 VGND VGND VPWR VPWR sky130_fd_sc_hd__decap_3
XFILLER_13_256 VGND VGND VPWR VPWR sky130_fd_sc_hd__decap_3
XFILLER_9_205 VGND VGND VPWR VPWR sky130_fd_sc_hd__decap_3
XFILLER_70_21 VGND VGND VPWR VPWR sky130_fd_sc_hd__decap_3
XFILLER_70_32 VGND VGND VPWR VPWR sky130_fd_sc_hd__decap_3
XFILLER_9_249 VGND VGND VPWR VPWR sky130_fd_sc_hd__decap_3
XFILLER_70_54 VGND VGND VPWR VPWR sky130_fd_sc_hd__decap_3
Xclkload19 _6929_/CLK VGND VGND VPWR VPWR clkload19/X sky130_fd_sc_hd__clkbuf_1
XFILLER_114_309 VGND VGND VPWR VPWR sky130_fd_sc_hd__decap_3
XFILLER_107_361 VGND VGND VPWR VPWR sky130_fd_sc_hd__fill_2
XFILLER_79_63 VGND VGND VPWR VPWR sky130_fd_sc_hd__decap_3
XFILLER_48_9 VGND VGND VPWR VPWR sky130_fd_sc_hd__fill_2
XFILLER_110_515 VGND VGND VPWR VPWR sky130_fd_sc_hd__decap_3
XFILLER_68_407 VGND VGND VPWR VPWR sky130_fd_sc_hd__decap_3
XFILLER_110_526 VGND VGND VPWR VPWR sky130_fd_sc_hd__decap_3
XFILLER_95_237 VGND VGND VPWR VPWR sky130_fd_sc_hd__decap_3
XFILLER_0_193 VGND VGND VPWR VPWR sky130_fd_sc_hd__decap_3
XFILLER_48_131 VGND VGND VPWR VPWR sky130_fd_sc_hd__decap_3
XFILLER_64_602 VGND VGND VPWR VPWR sky130_fd_sc_hd__decap_3
XFILLER_36_315 VGND VGND VPWR VPWR sky130_fd_sc_hd__decap_3
XFILLER_48_175 VGND VGND VPWR VPWR sky130_fd_sc_hd__decap_3
XFILLER_48_186 VGND VGND VPWR VPWR sky130_fd_sc_hd__decap_3
XFILLER_63_101 VGND VGND VPWR VPWR sky130_fd_sc_hd__decap_3
XFILLER_64_613 VGND VGND VPWR VPWR sky130_fd_sc_hd__decap_3
XFILLER_76_495 VGND VGND VPWR VPWR sky130_fd_sc_hd__decap_3
XFILLER_95_95 VGND VGND VPWR VPWR sky130_fd_sc_hd__decap_3
XTAP_TAPCELL_ROW_47_811 VGND VPWR sky130_fd_sc_hd__tapvpwrvgnd_1
XFILLER_48_197 VGND VGND VPWR VPWR sky130_fd_sc_hd__decap_3
XFILLER_63_145 VGND VGND VPWR VPWR sky130_fd_sc_hd__decap_3
XFILLER_91_443 VGND VGND VPWR VPWR sky130_fd_sc_hd__decap_3
XFILLER_51_329 VGND VGND VPWR VPWR sky130_fd_sc_hd__decap_3
XFILLER_91_487 VGND VGND VPWR VPWR sky130_fd_sc_hd__fill_1
X_3920_ hold983/X _5138_/S _3919_/X VGND VGND VPWR VPWR _7377_/D sky130_fd_sc_hd__o21a_2
XTAP_TAPCELL_ROW_63_1013 VGND VPWR sky130_fd_sc_hd__tapvpwrvgnd_1
XTAP_TAPCELL_ROW_63_1002 VGND VPWR sky130_fd_sc_hd__tapvpwrvgnd_1
X_3851_ _6825_/Q _3852_/A2 _3853_/A2 _6815_/Q _3850_/X VGND VGND VPWR VPWR _3851_/X
+ sky130_fd_sc_hd__a221o_2
XFILLER_81_3 VGND VGND VPWR VPWR sky130_fd_sc_hd__decap_3
X_6570_ _6570_/A VGND VGND VPWR VPWR _6570_/Y sky130_fd_sc_hd__inv_2
X_3782_ _6827_/Q _3852_/A2 _3853_/A2 _6817_/Q VGND VGND VPWR VPWR _3782_/X sky130_fd_sc_hd__a22o_2
XFILLER_8_271 VGND VGND VPWR VPWR sky130_fd_sc_hd__decap_3
XFILLER_105_309 VGND VGND VPWR VPWR sky130_fd_sc_hd__decap_3
Xoutput502 _3392_/A VGND VGND VPWR VPWR instruction_out[15] sky130_fd_sc_hd__clkdlybuf4s25_1
Xoutput535 _7010_/Q VGND VGND VPWR VPWR pc_out[1] sky130_fd_sc_hd__clkdlybuf4s25_1
Xoutput524 _7009_/Q VGND VGND VPWR VPWR pc_out[0] sky130_fd_sc_hd__clkdlybuf4s25_1
Xoutput513 _5648_/A VGND VGND VPWR VPWR instruction_out[27] sky130_fd_sc_hd__clkdlybuf4s25_1
X_5383_ _5383_/A0 _4878_/X _5383_/S VGND VGND VPWR VPWR _7141_/D sky130_fd_sc_hd__mux2_2
X_4403_ _4403_/A VGND VGND VPWR VPWR _4411_/A sky130_fd_sc_hd__inv_2
XFILLER_113_320 VGND VGND VPWR VPWR sky130_fd_sc_hd__decap_3
XFILLER_5_60 VGND VGND VPWR VPWR sky130_fd_sc_hd__decap_3
X_7122_ clkload7/A _7122_/D _6402_/Y VGND VGND VPWR VPWR _7122_/Q sky130_fd_sc_hd__dfrtp_2
Xoutput546 _6979_/Q VGND VGND VPWR VPWR pc_out[2] sky130_fd_sc_hd__clkdlybuf4s25_1
X_4334_ _7351_/Q _3449_/X _4334_/B1 _7159_/Q VGND VGND VPWR VPWR _4336_/B sky130_fd_sc_hd__a22o_2
XTAP_TAPCELL_ROW_74_1142 VGND VPWR sky130_fd_sc_hd__tapvpwrvgnd_1
XFILLER_99_532 VGND VGND VPWR VPWR sky130_fd_sc_hd__decap_3
XFILLER_113_364 VGND VGND VPWR VPWR sky130_fd_sc_hd__decap_3
XFILLER_59_429 VGND VGND VPWR VPWR sky130_fd_sc_hd__decap_3
X_7053_ _7368_/CLK _7053_/D _6333_/Y VGND VGND VPWR VPWR _7053_/Q sky130_fd_sc_hd__dfrtp_2
XFILLER_99_587 VGND VGND VPWR VPWR sky130_fd_sc_hd__decap_3
XFILLER_101_526 VGND VGND VPWR VPWR sky130_fd_sc_hd__decap_3
XFILLER_115_39 VGND VGND VPWR VPWR sky130_fd_sc_hd__decap_3
XFILLER_86_215 VGND VGND VPWR VPWR sky130_fd_sc_hd__decap_3
XFILLER_86_248 VGND VGND VPWR VPWR sky130_fd_sc_hd__decap_3
X_4265_ _7070_/Q _4265_/B VGND VGND VPWR VPWR _4376_/C sky130_fd_sc_hd__nor2_2
XFILLER_39_131 VGND VGND VPWR VPWR sky130_fd_sc_hd__decap_3
XFILLER_86_259 VGND VGND VPWR VPWR sky130_fd_sc_hd__decap_3
X_4196_ _7391_/Q _4196_/A2 _5028_/S _7295_/Q _4195_/X VGND VGND VPWR VPWR _4196_/X
+ sky130_fd_sc_hd__a221o_2
XFILLER_39_164 VGND VGND VPWR VPWR sky130_fd_sc_hd__decap_3
XFILLER_39_175 VGND VGND VPWR VPWR sky130_fd_sc_hd__fill_1
XFILLER_67_484 VGND VGND VPWR VPWR sky130_fd_sc_hd__decap_3
XFILLER_27_337 VGND VGND VPWR VPWR sky130_fd_sc_hd__decap_3
XFILLER_54_112 VGND VGND VPWR VPWR sky130_fd_sc_hd__decap_3
XFILLER_55_668 VGND VGND VPWR VPWR sky130_fd_sc_hd__decap_3
XFILLER_82_421 VGND VGND VPWR VPWR sky130_fd_sc_hd__decap_3
XFILLER_82_454 VGND VGND VPWR VPWR sky130_fd_sc_hd__decap_3
XFILLER_54_156 VGND VGND VPWR VPWR sky130_fd_sc_hd__decap_3
XFILLER_70_616 VGND VGND VPWR VPWR sky130_fd_sc_hd__decap_3
XFILLER_24_14 VGND VGND VPWR VPWR sky130_fd_sc_hd__decap_3
X_6906_ _6909_/CLK _6906_/D VGND VGND VPWR VPWR _6906_/Q sky130_fd_sc_hd__dfxtp_2
XTAP_TAPCELL_ROW_85_1271 VGND VPWR sky130_fd_sc_hd__tapvpwrvgnd_1
XTAP_TAPCELL_ROW_25_549 VGND VPWR sky130_fd_sc_hd__tapvpwrvgnd_1
XFILLER_50_351 VGND VGND VPWR VPWR sky130_fd_sc_hd__decap_3
X_6837_ _6978_/CLK _6837_/D VGND VGND VPWR VPWR _6837_/Q sky130_fd_sc_hd__dfxtp_2
XFILLER_50_384 VGND VGND VPWR VPWR sky130_fd_sc_hd__decap_3
X_6768_ _6909_/CLK _6768_/D VGND VGND VPWR VPWR _6768_/Q sky130_fd_sc_hd__dfxtp_2
XFILLER_108_103 VGND VGND VPWR VPWR sky130_fd_sc_hd__decap_3
XFILLER_40_24 VGND VGND VPWR VPWR sky130_fd_sc_hd__decap_3
XFILLER_40_35 VGND VGND VPWR VPWR sky130_fd_sc_hd__decap_3
X_6699_ clkload1/A _6699_/D VGND VGND VPWR VPWR _6699_/Q sky130_fd_sc_hd__dfxtp_2
X_5719_ _7365_/Q hold933/X _5729_/S VGND VGND VPWR VPWR _6709_/D sky130_fd_sc_hd__mux2_2
XFILLER_108_158 VGND VGND VPWR VPWR sky130_fd_sc_hd__decap_3
XFILLER_104_342 VGND VGND VPWR VPWR sky130_fd_sc_hd__decap_3
XFILLER_49_33 VGND VGND VPWR VPWR sky130_fd_sc_hd__fill_2
XFILLER_104_397 VGND VGND VPWR VPWR sky130_fd_sc_hd__decap_3
XFILLER_49_66 VGND VGND VPWR VPWR sky130_fd_sc_hd__decap_3
XFILLER_77_237 VGND VGND VPWR VPWR sky130_fd_sc_hd__decap_3
XFILLER_105_50 VGND VGND VPWR VPWR sky130_fd_sc_hd__decap_3
XFILLER_1_29 VGND VGND VPWR VPWR sky130_fd_sc_hd__decap_3
XFILLER_58_451 VGND VGND VPWR VPWR sky130_fd_sc_hd__decap_3
XFILLER_105_72 VGND VGND VPWR VPWR sky130_fd_sc_hd__decap_3
XFILLER_18_315 VGND VGND VPWR VPWR sky130_fd_sc_hd__decap_3
XFILLER_45_101 VGND VGND VPWR VPWR sky130_fd_sc_hd__fill_1
XFILLER_65_32 VGND VGND VPWR VPWR sky130_fd_sc_hd__decap_3
XFILLER_73_410 VGND VGND VPWR VPWR sky130_fd_sc_hd__decap_3
XFILLER_92_229 VGND VGND VPWR VPWR sky130_fd_sc_hd__decap_3
XFILLER_45_134 VGND VGND VPWR VPWR sky130_fd_sc_hd__decap_3
XFILLER_65_76 VGND VGND VPWR VPWR sky130_fd_sc_hd__fill_1
XFILLER_73_454 VGND VGND VPWR VPWR sky130_fd_sc_hd__decap_3
XFILLER_85_281 VGND VGND VPWR VPWR sky130_fd_sc_hd__decap_3
XFILLER_33_318 VGND VGND VPWR VPWR sky130_fd_sc_hd__decap_3
XFILLER_45_167 VGND VGND VPWR VPWR sky130_fd_sc_hd__fill_1
XFILLER_46_679 VGND VGND VPWR VPWR sky130_fd_sc_hd__decap_3
XFILLER_65_98 VGND VGND VPWR VPWR sky130_fd_sc_hd__decap_3
XFILLER_73_487 VGND VGND VPWR VPWR sky130_fd_sc_hd__decap_3
XFILLER_26_392 VGND VGND VPWR VPWR sky130_fd_sc_hd__decap_3
XFILLER_41_340 VGND VGND VPWR VPWR sky130_fd_sc_hd__decap_3
XFILLER_60_148 VGND VGND VPWR VPWR sky130_fd_sc_hd__fill_2
XFILLER_81_31 VGND VGND VPWR VPWR sky130_fd_sc_hd__fill_2
XFILLER_81_53 VGND VGND VPWR VPWR sky130_fd_sc_hd__decap_3
XFILLER_81_75 VGND VGND VPWR VPWR sky130_fd_sc_hd__decap_3
XTAP_TAPCELL_ROW_52_880 VGND VPWR sky130_fd_sc_hd__tapvpwrvgnd_1
XFILLER_14_80 VGND VGND VPWR VPWR sky130_fd_sc_hd__decap_3
XFILLER_14_91 VGND VGND VPWR VPWR sky130_fd_sc_hd__decap_3
XFILLER_114_139 VGND VGND VPWR VPWR sky130_fd_sc_hd__fill_1
XFILLER_5_274 VGND VGND VPWR VPWR sky130_fd_sc_hd__decap_3
XFILLER_5_296 VGND VGND VPWR VPWR sky130_fd_sc_hd__decap_3
XFILLER_96_513 VGND VGND VPWR VPWR sky130_fd_sc_hd__decap_3
XFILLER_110_312 VGND VGND VPWR VPWR sky130_fd_sc_hd__decap_3
XFILLER_68_215 VGND VGND VPWR VPWR sky130_fd_sc_hd__decap_3
XFILLER_110_334 VGND VGND VPWR VPWR sky130_fd_sc_hd__decap_3
XFILLER_96_557 VGND VGND VPWR VPWR sky130_fd_sc_hd__decap_3
X_4050_ _7053_/Q _4491_/S _4399_/A2 _7405_/Q _4049_/X VGND VGND VPWR VPWR _4050_/X
+ sky130_fd_sc_hd__a221o_2
XFILLER_110_389 VGND VGND VPWR VPWR sky130_fd_sc_hd__decap_3
XFILLER_37_613 VGND VGND VPWR VPWR sky130_fd_sc_hd__decap_3
XFILLER_49_462 VGND VGND VPWR VPWR sky130_fd_sc_hd__fill_1
XFILLER_49_484 VGND VGND VPWR VPWR sky130_fd_sc_hd__decap_3
XFILLER_76_270 VGND VGND VPWR VPWR sky130_fd_sc_hd__decap_3
XFILLER_49_495 VGND VGND VPWR VPWR sky130_fd_sc_hd__fill_1
XFILLER_64_421 VGND VGND VPWR VPWR sky130_fd_sc_hd__fill_1
XTAP_TAPCELL_ROW_108_1547 VGND VPWR sky130_fd_sc_hd__tapvpwrvgnd_1
XFILLER_24_307 VGND VGND VPWR VPWR sky130_fd_sc_hd__fill_1
XFILLER_24_318 VGND VGND VPWR VPWR sky130_fd_sc_hd__decap_3
XFILLER_36_167 VGND VGND VPWR VPWR sky130_fd_sc_hd__decap_3
XFILLER_64_465 VGND VGND VPWR VPWR sky130_fd_sc_hd__decap_3
XFILLER_91_262 VGND VGND VPWR VPWR sky130_fd_sc_hd__decap_3
XFILLER_17_370 VGND VGND VPWR VPWR sky130_fd_sc_hd__decap_3
XFILLER_45_690 VGND VGND VPWR VPWR sky130_fd_sc_hd__fill_2
XFILLER_51_104 VGND VGND VPWR VPWR sky130_fd_sc_hd__decap_3
XFILLER_91_273 VGND VGND VPWR VPWR sky130_fd_sc_hd__decap_3
XFILLER_91_284 VGND VGND VPWR VPWR sky130_fd_sc_hd__decap_3
X_4952_ _4967_/B _4968_/A VGND VGND VPWR VPWR _4969_/C sky130_fd_sc_hd__or2b_2
XFILLER_51_148 VGND VGND VPWR VPWR sky130_fd_sc_hd__decap_3
X_3903_ _6782_/Q _3926_/B1 _3925_/A2 _6692_/Q _3902_/X VGND VGND VPWR VPWR _3904_/B
+ sky130_fd_sc_hd__a221o_2
X_6622_ _6683_/A VGND VGND VPWR VPWR _6622_/Y sky130_fd_sc_hd__inv_2
XTAP_TAPCELL_ROW_22_519 VGND VPWR sky130_fd_sc_hd__tapvpwrvgnd_1
XFILLER_20_568 VGND VGND VPWR VPWR sky130_fd_sc_hd__decap_3
X_6553_ _6553_/A VGND VGND VPWR VPWR _6553_/Y sky130_fd_sc_hd__inv_2
X_3765_ _3629_/Y _3764_/X _3818_/A2 VGND VGND VPWR VPWR _4927_/B sky130_fd_sc_hd__o21a_2
X_6484_ _6642_/A VGND VGND VPWR VPWR _6484_/Y sky130_fd_sc_hd__inv_2
X_3696_ _6940_/Q _3828_/A2 _3922_/A2 _6804_/Q _3695_/X VGND VGND VPWR VPWR _3696_/X
+ sky130_fd_sc_hd__a221o_2
XFILLER_10_16 VGND VGND VPWR VPWR sky130_fd_sc_hd__decap_3
XFILLER_10_49 VGND VGND VPWR VPWR sky130_fd_sc_hd__decap_3
XFILLER_99_340 VGND VGND VPWR VPWR sky130_fd_sc_hd__decap_3
XFILLER_113_161 VGND VGND VPWR VPWR sky130_fd_sc_hd__decap_3
XFILLER_113_172 VGND VGND VPWR VPWR sky130_fd_sc_hd__decap_3
XFILLER_59_215 VGND VGND VPWR VPWR sky130_fd_sc_hd__decap_3
XFILLER_59_237 VGND VGND VPWR VPWR sky130_fd_sc_hd__decap_3
XFILLER_87_535 VGND VGND VPWR VPWR sky130_fd_sc_hd__decap_3
X_7105_ _7362_/CLK _7105_/D _6385_/Y VGND VGND VPWR VPWR _7105_/Q sky130_fd_sc_hd__dfrtp_2
X_4317_ _7322_/Q _3996_/S _3380_/Y _7354_/Q _4248_/A VGND VGND VPWR VPWR _4317_/X
+ sky130_fd_sc_hd__a221o_2
XFILLER_99_373 VGND VGND VPWR VPWR sky130_fd_sc_hd__decap_3
XFILLER_19_14 VGND VGND VPWR VPWR sky130_fd_sc_hd__decap_3
XFILLER_87_579 VGND VGND VPWR VPWR sky130_fd_sc_hd__decap_3
X_7036_ _7381_/CLK _7036_/D _6316_/Y VGND VGND VPWR VPWR _7036_/Q sky130_fd_sc_hd__dfrtp_2
X_4248_ _4248_/A _4248_/B _4248_/C VGND VGND VPWR VPWR _4626_/B sky130_fd_sc_hd__or3_4
XFILLER_101_378 VGND VGND VPWR VPWR sky130_fd_sc_hd__decap_3
XFILLER_74_218 VGND VGND VPWR VPWR sky130_fd_sc_hd__decap_3
XTAP_TAPCELL_ROW_87_1300 VGND VPWR sky130_fd_sc_hd__tapvpwrvgnd_1
XFILLER_27_134 VGND VGND VPWR VPWR sky130_fd_sc_hd__decap_3
XFILLER_55_421 VGND VGND VPWR VPWR sky130_fd_sc_hd__decap_3
XFILLER_67_281 VGND VGND VPWR VPWR sky130_fd_sc_hd__decap_3
X_4179_ _4173_/Y _4188_/C1 _4376_/A _4178_/Y VGND VGND VPWR VPWR _4186_/A sky130_fd_sc_hd__a211o_2
XFILLER_15_307 VGND VGND VPWR VPWR sky130_fd_sc_hd__decap_3
XFILLER_27_167 VGND VGND VPWR VPWR sky130_fd_sc_hd__fill_1
XFILLER_35_24 VGND VGND VPWR VPWR sky130_fd_sc_hd__decap_3
XFILLER_55_476 VGND VGND VPWR VPWR sky130_fd_sc_hd__decap_3
XFILLER_82_262 VGND VGND VPWR VPWR sky130_fd_sc_hd__decap_3
XTAP_TAPCELL_ROW_2_277 VGND VPWR sky130_fd_sc_hd__tapvpwrvgnd_1
XFILLER_27_178 VGND VGND VPWR VPWR sky130_fd_sc_hd__decap_3
XFILLER_35_57 VGND VGND VPWR VPWR sky130_fd_sc_hd__decap_3
XFILLER_42_115 VGND VGND VPWR VPWR sky130_fd_sc_hd__decap_3
XFILLER_70_424 VGND VGND VPWR VPWR sky130_fd_sc_hd__decap_3
XFILLER_70_435 VGND VGND VPWR VPWR sky130_fd_sc_hd__decap_3
XFILLER_70_468 VGND VGND VPWR VPWR sky130_fd_sc_hd__decap_3
XFILLER_51_12 VGND VGND VPWR VPWR sky130_fd_sc_hd__decap_3
XFILLER_11_557 VGND VGND VPWR VPWR sky130_fd_sc_hd__decap_3
XFILLER_50_192 VGND VGND VPWR VPWR sky130_fd_sc_hd__decap_3
Xclkbuf_3_3__f_clk clkbuf_0_clk/X VGND VGND VPWR VPWR clkbuf_3_3__f_clk/X sky130_fd_sc_hd__clkbuf_16
XPHY_EDGE_ROW_14_Right_14 VGND VGND VPWR VPWR sky130_fd_sc_hd__decap_3
XFILLER_51_78 VGND VGND VPWR VPWR sky130_fd_sc_hd__decap_3
XFILLER_109_434 VGND VGND VPWR VPWR sky130_fd_sc_hd__decap_3
XFILLER_2_222 VGND VGND VPWR VPWR sky130_fd_sc_hd__decap_3
XFILLER_104_161 VGND VGND VPWR VPWR sky130_fd_sc_hd__decap_3
XFILLER_2_299 VGND VGND VPWR VPWR sky130_fd_sc_hd__fill_1
XPHY_EDGE_ROW_23_Right_23 VGND VGND VPWR VPWR sky130_fd_sc_hd__decap_3
XFILLER_116_71 VGND VGND VPWR VPWR sky130_fd_sc_hd__decap_3
XFILLER_93_505 VGND VGND VPWR VPWR sky130_fd_sc_hd__decap_3
XFILLER_76_53 VGND VGND VPWR VPWR sky130_fd_sc_hd__decap_3
XFILLER_46_465 VGND VGND VPWR VPWR sky130_fd_sc_hd__decap_3
XFILLER_73_240 VGND VGND VPWR VPWR sky130_fd_sc_hd__decap_3
Xplace74 _5656_/C VGND VGND VPWR VPWR place74/X sky130_fd_sc_hd__buf_2
XFILLER_18_178 VGND VGND VPWR VPWR sky130_fd_sc_hd__decap_3
XFILLER_33_126 VGND VGND VPWR VPWR sky130_fd_sc_hd__decap_3
XFILLER_61_435 VGND VGND VPWR VPWR sky130_fd_sc_hd__decap_3
XFILLER_73_284 VGND VGND VPWR VPWR sky130_fd_sc_hd__decap_3
XFILLER_73_295 VGND VGND VPWR VPWR sky130_fd_sc_hd__decap_3
XFILLER_92_41 VGND VGND VPWR VPWR sky130_fd_sc_hd__fill_2
XFILLER_92_85 VGND VGND VPWR VPWR sky130_fd_sc_hd__decap_3
XPHY_EDGE_ROW_32_Right_32 VGND VGND VPWR VPWR sky130_fd_sc_hd__decap_3
XFILLER_25_90 VGND VGND VPWR VPWR sky130_fd_sc_hd__decap_3
XTAP_TAPCELL_ROW_103_1488 VGND VPWR sky130_fd_sc_hd__tapvpwrvgnd_1
X_3550_ _4614_/A _3547_/A _3547_/B _3548_/X VGND VGND VPWR VPWR _3550_/X sky130_fd_sc_hd__a31o_2
X_3481_ _7344_/Q _4337_/B _5080_/S _7280_/Q VGND VGND VPWR VPWR _3482_/C sky130_fd_sc_hd__a22o_2
XFILLER_102_109 VGND VGND VPWR VPWR sky130_fd_sc_hd__decap_3
XFILLER_44_3 VGND VGND VPWR VPWR sky130_fd_sc_hd__decap_3
XTAP_TAPCELL_ROW_71_1101 VGND VPWR sky130_fd_sc_hd__tapvpwrvgnd_1
XPHY_EDGE_ROW_41_Right_41 VGND VGND VPWR VPWR sky130_fd_sc_hd__decap_3
XFILLER_69_535 VGND VGND VPWR VPWR sky130_fd_sc_hd__decap_3
XFILLER_96_321 VGND VGND VPWR VPWR sky130_fd_sc_hd__decap_3
X_5151_ _5151_/A _5659_/B VGND VGND VPWR VPWR _5151_/X sky130_fd_sc_hd__or2_2
XFILLER_96_354 VGND VGND VPWR VPWR sky130_fd_sc_hd__decap_3
X_5082_ _6986_/Q _5098_/A VGND VGND VPWR VPWR _6986_/D sky130_fd_sc_hd__xor2_2
X_4102_ _7077_/Q _4265_/B VGND VGND VPWR VPWR _4141_/B sky130_fd_sc_hd__nor2_2
XFILLER_2_61 VGND VGND VPWR VPWR sky130_fd_sc_hd__decap_3
XFILLER_56_218 VGND VGND VPWR VPWR sky130_fd_sc_hd__decap_3
XFILLER_84_516 VGND VGND VPWR VPWR sky130_fd_sc_hd__decap_3
XFILLER_96_365 VGND VGND VPWR VPWR sky130_fd_sc_hd__decap_3
X_4033_ _7054_/Q _4491_/S _4399_/A2 _7406_/Q VGND VGND VPWR VPWR _4033_/X sky130_fd_sc_hd__a22o_2
XFILLER_37_432 VGND VGND VPWR VPWR sky130_fd_sc_hd__decap_3
XFILLER_49_281 VGND VGND VPWR VPWR sky130_fd_sc_hd__decap_3
XFILLER_112_18 VGND VGND VPWR VPWR sky130_fd_sc_hd__decap_3
XFILLER_112_29 VGND VGND VPWR VPWR sky130_fd_sc_hd__fill_1
XFILLER_37_476 VGND VGND VPWR VPWR sky130_fd_sc_hd__decap_3
XFILLER_52_402 VGND VGND VPWR VPWR sky130_fd_sc_hd__decap_3
XFILLER_64_240 VGND VGND VPWR VPWR sky130_fd_sc_hd__decap_3
XTAP_TAPCELL_ROW_55_909 VGND VPWR sky130_fd_sc_hd__tapvpwrvgnd_1
XFILLER_24_104 VGND VGND VPWR VPWR sky130_fd_sc_hd__decap_3
XFILLER_37_498 VGND VGND VPWR VPWR sky130_fd_sc_hd__decap_3
XFILLER_52_424 VGND VGND VPWR VPWR sky130_fd_sc_hd__decap_3
XTAP_TAPCELL_ROW_69_1085 VGND VPWR sky130_fd_sc_hd__tapvpwrvgnd_1
XTAP_TAPCELL_ROW_69_1074 VGND VPWR sky130_fd_sc_hd__tapvpwrvgnd_1
XPHY_EDGE_ROW_50_Right_50 VGND VGND VPWR VPWR sky130_fd_sc_hd__decap_3
XFILLER_24_137 VGND VGND VPWR VPWR sky130_fd_sc_hd__decap_3
XFILLER_24_159 VGND VGND VPWR VPWR sky130_fd_sc_hd__decap_3
XTAP_TAPCELL_ROW_82_1241 VGND VPWR sky130_fd_sc_hd__tapvpwrvgnd_1
XTAP_TAPCELL_ROW_82_1230 VGND VPWR sky130_fd_sc_hd__tapvpwrvgnd_1
X_4935_ _6995_/Q _4963_/A VGND VGND VPWR VPWR _6995_/D sky130_fd_sc_hd__xor2_2
XTAP_TAPCELL_ROW_35_677 VGND VPWR sky130_fd_sc_hd__tapvpwrvgnd_1
XTAP_TAPCELL_ROW_35_666 VGND VPWR sky130_fd_sc_hd__tapvpwrvgnd_1
XANTENNA_11 _5094_/X VGND VGND VPWR VPWR sky130_fd_sc_hd__diode_2
XANTENNA_22 _7372_/Q VGND VGND VPWR VPWR sky130_fd_sc_hd__diode_2
XFILLER_20_321 VGND VGND VPWR VPWR sky130_fd_sc_hd__decap_3
XANTENNA_33 _3525_/A VGND VGND VPWR VPWR sky130_fd_sc_hd__diode_2
XFILLER_20_354 VGND VGND VPWR VPWR sky130_fd_sc_hd__decap_3
XFILLER_20_365 VGND VGND VPWR VPWR sky130_fd_sc_hd__decap_3
X_6605_ _6638_/A VGND VGND VPWR VPWR _6605_/Y sky130_fd_sc_hd__inv_2
X_4797_ _4891_/A1 _4648_/A _4795_/A _5033_/B2 VGND VGND VPWR VPWR _4797_/X sky130_fd_sc_hd__a22o_2
X_3817_ _3629_/A _3816_/X _4791_/A1 VGND VGND VPWR VPWR _3817_/X sky130_fd_sc_hd__a21o_2
XFILLER_21_37 VGND VGND VPWR VPWR sky130_fd_sc_hd__decap_3
X_6536_ _6536_/A VGND VGND VPWR VPWR _6536_/Y sky130_fd_sc_hd__inv_2
X_3748_ _3735_/X _3738_/X _3740_/X _3682_/A _3747_/X VGND VGND VPWR VPWR _3748_/X
+ sky130_fd_sc_hd__a221o_2
XFILLER_106_448 VGND VGND VPWR VPWR sky130_fd_sc_hd__decap_3
X_6467_ _6635_/A VGND VGND VPWR VPWR _6467_/Y sky130_fd_sc_hd__inv_2
X_3679_ _6894_/Q VGND VGND VPWR VPWR _3679_/Y sky130_fd_sc_hd__inv_2
X_6398_ _6647_/A VGND VGND VPWR VPWR _6398_/Y sky130_fd_sc_hd__inv_2
XTAP_TAPCELL_ROW_93_1370 VGND VPWR sky130_fd_sc_hd__tapvpwrvgnd_1
XTAP_TAPCELL_ROW_7_336 VGND VPWR sky130_fd_sc_hd__tapvpwrvgnd_1
XFILLER_102_632 VGND VGND VPWR VPWR sky130_fd_sc_hd__decap_3
XFILLER_87_332 VGND VGND VPWR VPWR sky130_fd_sc_hd__decap_3
XFILLER_87_343 VGND VGND VPWR VPWR sky130_fd_sc_hd__decap_3
XFILLER_101_142 VGND VGND VPWR VPWR sky130_fd_sc_hd__fill_2
XFILLER_102_687 VGND VGND VPWR VPWR sky130_fd_sc_hd__decap_3
XFILLER_47_218 VGND VGND VPWR VPWR sky130_fd_sc_hd__decap_3
XFILLER_75_505 VGND VGND VPWR VPWR sky130_fd_sc_hd__fill_1
XFILLER_75_516 VGND VGND VPWR VPWR sky130_fd_sc_hd__decap_3
XFILLER_87_376 VGND VGND VPWR VPWR sky130_fd_sc_hd__decap_3
XFILLER_28_421 VGND VGND VPWR VPWR sky130_fd_sc_hd__fill_1
XFILLER_75_549 VGND VGND VPWR VPWR sky130_fd_sc_hd__decap_3
X_7019_ _7359_/CLK _7019_/D _6299_/Y VGND VGND VPWR VPWR _7019_/Q sky130_fd_sc_hd__dfrtp_2
XFILLER_28_443 VGND VGND VPWR VPWR sky130_fd_sc_hd__decap_3
XFILLER_55_240 VGND VGND VPWR VPWR sky130_fd_sc_hd__decap_3
XFILLER_55_273 VGND VGND VPWR VPWR sky130_fd_sc_hd__decap_3
XFILLER_83_582 VGND VGND VPWR VPWR sky130_fd_sc_hd__decap_3
XFILLER_102_40 VGND VGND VPWR VPWR sky130_fd_sc_hd__decap_3
XFILLER_102_73 VGND VGND VPWR VPWR sky130_fd_sc_hd__fill_2
XFILLER_15_159 VGND VGND VPWR VPWR sky130_fd_sc_hd__decap_3
XFILLER_43_457 VGND VGND VPWR VPWR sky130_fd_sc_hd__fill_1
XFILLER_70_232 VGND VGND VPWR VPWR sky130_fd_sc_hd__decap_3
XFILLER_62_55 VGND VGND VPWR VPWR sky130_fd_sc_hd__decap_3
XFILLER_70_265 VGND VGND VPWR VPWR sky130_fd_sc_hd__fill_2
XFILLER_11_321 VGND VGND VPWR VPWR sky130_fd_sc_hd__decap_3
XFILLER_23_181 VGND VGND VPWR VPWR sky130_fd_sc_hd__fill_1
XFILLER_30_129 VGND VGND VPWR VPWR sky130_fd_sc_hd__decap_3
XFILLER_62_88 VGND VGND VPWR VPWR sky130_fd_sc_hd__decap_3
XFILLER_11_343 VGND VGND VPWR VPWR sky130_fd_sc_hd__decap_3
XFILLER_7_314 VGND VGND VPWR VPWR sky130_fd_sc_hd__decap_3
XFILLER_109_264 VGND VGND VPWR VPWR sky130_fd_sc_hd__decap_3
XFILLER_7_358 VGND VGND VPWR VPWR sky130_fd_sc_hd__decap_3
XFILLER_112_407 VGND VGND VPWR VPWR sky130_fd_sc_hd__decap_3
XFILLER_11_81 VGND VGND VPWR VPWR sky130_fd_sc_hd__decap_3
XFILLER_105_470 VGND VGND VPWR VPWR sky130_fd_sc_hd__decap_3
XFILLER_87_30 VGND VGND VPWR VPWR sky130_fd_sc_hd__decap_3
XFILLER_87_52 VGND VGND VPWR VPWR sky130_fd_sc_hd__decap_3
XFILLER_78_321 VGND VGND VPWR VPWR sky130_fd_sc_hd__decap_3
XFILLER_66_516 VGND VGND VPWR VPWR sky130_fd_sc_hd__decap_3
XFILLER_78_365 VGND VGND VPWR VPWR sky130_fd_sc_hd__decap_3
XFILLER_93_313 VGND VGND VPWR VPWR sky130_fd_sc_hd__decap_3
XFILLER_19_432 VGND VGND VPWR VPWR sky130_fd_sc_hd__decap_3
XFILLER_78_398 VGND VGND VPWR VPWR sky130_fd_sc_hd__fill_1
XFILLER_93_346 VGND VGND VPWR VPWR sky130_fd_sc_hd__decap_3
XFILLER_74_560 VGND VGND VPWR VPWR sky130_fd_sc_hd__decap_3
XFILLER_93_379 VGND VGND VPWR VPWR sky130_fd_sc_hd__decap_3
XFILLER_46_273 VGND VGND VPWR VPWR sky130_fd_sc_hd__decap_3
XTAP_TAPCELL_ROW_105_1517 VGND VPWR sky130_fd_sc_hd__tapvpwrvgnd_1
XTAP_TAPCELL_ROW_105_1506 VGND VPWR sky130_fd_sc_hd__tapvpwrvgnd_1
XFILLER_21_107 VGND VGND VPWR VPWR sky130_fd_sc_hd__decap_3
XFILLER_61_265 VGND VGND VPWR VPWR sky130_fd_sc_hd__decap_3
Xclkbuf_leaf_41_clk clkbuf_leaf_9_clk/A VGND VGND VPWR VPWR _7360_/CLK sky130_fd_sc_hd__clkbuf_16
X_4720_ _4720_/A _4720_/B VGND VGND VPWR VPWR _4720_/X sky130_fd_sc_hd__xor2_2
XTAP_TAPCELL_ROW_32_636 VGND VPWR sky130_fd_sc_hd__tapvpwrvgnd_1
XFILLER_30_674 VGND VGND VPWR VPWR sky130_fd_sc_hd__fill_1
X_4651_ _4813_/A _4810_/B VGND VGND VPWR VPWR _4652_/B sky130_fd_sc_hd__and2_2
XTAP_TAPCELL_ROW_60_967 VGND VPWR sky130_fd_sc_hd__tapvpwrvgnd_1
X_3602_ _4614_/A _3547_/A _3547_/B _4614_/C _4613_/B VGND VGND VPWR VPWR _3603_/B
+ sky130_fd_sc_hd__a41o_2
X_7370_ _7403_/CLK _7370_/D _6650_/Y VGND VGND VPWR VPWR _7370_/Q sky130_fd_sc_hd__dfrtp_2
XTAP_TAPCELL_ROW_12_393 VGND VPWR sky130_fd_sc_hd__tapvpwrvgnd_1
XFILLER_6_380 VGND VGND VPWR VPWR sky130_fd_sc_hd__fill_2
Xhold804 _6905_/Q VGND VGND VPWR VPWR _6905_/D sky130_fd_sc_hd__dlygate4sd3_1
Xhold815 _6863_/Q VGND VGND VPWR VPWR _6863_/D sky130_fd_sc_hd__dlygate4sd3_1
Xhold826 _6819_/Q VGND VGND VPWR VPWR _6819_/D sky130_fd_sc_hd__dlygate4sd3_1
Xhold837 _6792_/Q VGND VGND VPWR VPWR _6792_/D sky130_fd_sc_hd__dlygate4sd3_1
X_6321_ _6674_/A VGND VGND VPWR VPWR _6321_/Y sky130_fd_sc_hd__inv_2
XTAP_TAPCELL_ROW_116_1657 VGND VPWR sky130_fd_sc_hd__tapvpwrvgnd_1
XTAP_TAPCELL_ROW_116_1646 VGND VPWR sky130_fd_sc_hd__tapvpwrvgnd_1
XFILLER_107_29 VGND VGND VPWR VPWR sky130_fd_sc_hd__decap_3
Xhold848 _7066_/Q VGND VGND VPWR VPWR _7066_/D sky130_fd_sc_hd__dlygate4sd3_1
Xhold859 _7071_/Q VGND VGND VPWR VPWR _7071_/D sky130_fd_sc_hd__dlygate4sd3_1
Xmax_cap578 _6275_/A VGND VGND VPWR VPWR _6523_/A sky130_fd_sc_hd__buf_4
Xmax_cap567 _4788_/A VGND VGND VPWR VPWR _4765_/A sky130_fd_sc_hd__buf_2
XFILLER_88_129 VGND VGND VPWR VPWR sky130_fd_sc_hd__decap_3
X_5203_ _5203_/A _5217_/B VGND VGND VPWR VPWR _7227_/D sky130_fd_sc_hd__and2_2
X_5134_ _3735_/A _3908_/X _3346_/A VGND VGND VPWR VPWR _5134_/X sky130_fd_sc_hd__o21a_2
X_3395_ _7059_/Q _3577_/B VGND VGND VPWR VPWR _3589_/B sky130_fd_sc_hd__nor2_2
XFILLER_97_641 VGND VGND VPWR VPWR sky130_fd_sc_hd__decap_3
XFILLER_57_505 VGND VGND VPWR VPWR sky130_fd_sc_hd__decap_3
XFILLER_69_387 VGND VGND VPWR VPWR sky130_fd_sc_hd__decap_3
XFILLER_96_162 VGND VGND VPWR VPWR sky130_fd_sc_hd__decap_3
XFILLER_84_335 VGND VGND VPWR VPWR sky130_fd_sc_hd__decap_3
XFILLER_96_195 VGND VGND VPWR VPWR sky130_fd_sc_hd__fill_1
X_5065_ _6986_/Q _5098_/A _6987_/Q VGND VGND VPWR VPWR _5066_/B sky130_fd_sc_hd__a21oi_2
XFILLER_37_240 VGND VGND VPWR VPWR sky130_fd_sc_hd__decap_3
XFILLER_72_508 VGND VGND VPWR VPWR sky130_fd_sc_hd__decap_3
XFILLER_84_368 VGND VGND VPWR VPWR sky130_fd_sc_hd__decap_3
XFILLER_16_15 VGND VGND VPWR VPWR sky130_fd_sc_hd__decap_3
XFILLER_37_284 VGND VGND VPWR VPWR sky130_fd_sc_hd__decap_3
XFILLER_16_48 VGND VGND VPWR VPWR sky130_fd_sc_hd__decap_3
XFILLER_12_107 VGND VGND VPWR VPWR sky130_fd_sc_hd__decap_3
XFILLER_25_479 VGND VGND VPWR VPWR sky130_fd_sc_hd__fill_2
XFILLER_40_405 VGND VGND VPWR VPWR sky130_fd_sc_hd__decap_3
XFILLER_40_427 VGND VGND VPWR VPWR sky130_fd_sc_hd__decap_3
XFILLER_52_265 VGND VGND VPWR VPWR sky130_fd_sc_hd__decap_3
XFILLER_21_630 VGND VGND VPWR VPWR sky130_fd_sc_hd__decap_3
Xclkbuf_leaf_32_clk clkbuf_3_2__f_clk/X VGND VGND VPWR VPWR _6978_/CLK sky130_fd_sc_hd__clkbuf_16
X_4918_ _4918_/A _4918_/B VGND VGND VPWR VPWR _4936_/B sky130_fd_sc_hd__nor2_2
X_4849_ _4872_/A _4872_/B VGND VGND VPWR VPWR _4849_/Y sky130_fd_sc_hd__nor2_2
XFILLER_106_212 VGND VGND VPWR VPWR sky130_fd_sc_hd__decap_3
XFILLER_4_339 VGND VGND VPWR VPWR sky130_fd_sc_hd__decap_3
X_6519_ _6553_/A VGND VGND VPWR VPWR _6519_/Y sky130_fd_sc_hd__inv_2
XFILLER_106_234 VGND VGND VPWR VPWR sky130_fd_sc_hd__decap_3
XFILLER_106_256 VGND VGND VPWR VPWR sky130_fd_sc_hd__decap_3
XFILLER_102_473 VGND VGND VPWR VPWR sky130_fd_sc_hd__decap_3
XFILLER_48_505 VGND VGND VPWR VPWR sky130_fd_sc_hd__decap_3
XFILLER_87_140 VGND VGND VPWR VPWR sky130_fd_sc_hd__decap_3
XFILLER_87_162 VGND VGND VPWR VPWR sky130_fd_sc_hd__decap_3
XFILLER_88_674 VGND VGND VPWR VPWR sky130_fd_sc_hd__decap_3
XFILLER_57_66 VGND VGND VPWR VPWR sky130_fd_sc_hd__decap_3
XFILLER_75_324 VGND VGND VPWR VPWR sky130_fd_sc_hd__decap_3
XFILLER_28_240 VGND VGND VPWR VPWR sky130_fd_sc_hd__decap_3
XFILLER_63_519 VGND VGND VPWR VPWR sky130_fd_sc_hd__decap_3
XFILLER_16_402 VGND VGND VPWR VPWR sky130_fd_sc_hd__fill_2
XFILLER_16_413 VGND VGND VPWR VPWR sky130_fd_sc_hd__decap_3
XFILLER_16_424 VGND VGND VPWR VPWR sky130_fd_sc_hd__decap_3
XFILLER_28_262 VGND VGND VPWR VPWR sky130_fd_sc_hd__decap_3
XFILLER_90_327 VGND VGND VPWR VPWR sky130_fd_sc_hd__decap_3
XFILLER_43_221 VGND VGND VPWR VPWR sky130_fd_sc_hd__decap_3
XFILLER_71_552 VGND VGND VPWR VPWR sky130_fd_sc_hd__fill_1
XFILLER_73_43 VGND VGND VPWR VPWR sky130_fd_sc_hd__decap_3
XFILLER_31_405 VGND VGND VPWR VPWR sky130_fd_sc_hd__decap_3
XFILLER_43_254 VGND VGND VPWR VPWR sky130_fd_sc_hd__decap_3
XFILLER_71_585 VGND VGND VPWR VPWR sky130_fd_sc_hd__decap_3
XFILLER_73_87 VGND VGND VPWR VPWR sky130_fd_sc_hd__decap_3
XFILLER_43_287 VGND VGND VPWR VPWR sky130_fd_sc_hd__decap_3
Xclkbuf_leaf_23_clk clkbuf_3_3__f_clk/X VGND VGND VPWR VPWR _7390_/CLK sky130_fd_sc_hd__clkbuf_16
XFILLER_11_140 VGND VGND VPWR VPWR sky130_fd_sc_hd__decap_3
XTAP_TAPCELL_ROW_100_1447 VGND VPWR sky130_fd_sc_hd__tapvpwrvgnd_1
XFILLER_7_166 VGND VGND VPWR VPWR sky130_fd_sc_hd__fill_2
XFILLER_22_80 VGND VGND VPWR VPWR sky130_fd_sc_hd__decap_3
XFILLER_7_199 VGND VGND VPWR VPWR sky130_fd_sc_hd__decap_3
XFILLER_98_51 VGND VGND VPWR VPWR sky130_fd_sc_hd__decap_3
XFILLER_112_215 VGND VGND VPWR VPWR sky130_fd_sc_hd__decap_3
XFILLER_3_372 VGND VGND VPWR VPWR sky130_fd_sc_hd__decap_3
XFILLER_98_427 VGND VGND VPWR VPWR sky130_fd_sc_hd__decap_3
XFILLER_112_259 VGND VGND VPWR VPWR sky130_fd_sc_hd__decap_3
XFILLER_79_641 VGND VGND VPWR VPWR sky130_fd_sc_hd__decap_3
XFILLER_94_600 VGND VGND VPWR VPWR sky130_fd_sc_hd__decap_3
XTAP_TAPCELL_ROW_111_1587 VGND VPWR sky130_fd_sc_hd__tapvpwrvgnd_1
XFILLER_66_335 VGND VGND VPWR VPWR sky130_fd_sc_hd__decap_3
XFILLER_78_173 VGND VGND VPWR VPWR sky130_fd_sc_hd__decap_3
XFILLER_94_633 VGND VGND VPWR VPWR sky130_fd_sc_hd__decap_3
XFILLER_19_240 VGND VGND VPWR VPWR sky130_fd_sc_hd__decap_3
XFILLER_66_368 VGND VGND VPWR VPWR sky130_fd_sc_hd__fill_1
XFILLER_19_284 VGND VGND VPWR VPWR sky130_fd_sc_hd__decap_3
XFILLER_81_349 VGND VGND VPWR VPWR sky130_fd_sc_hd__decap_3
X_6870_ _7383_/CLK _6870_/D VGND VGND VPWR VPWR _6870_/Q sky130_fd_sc_hd__dfxtp_2
XTAP_TAPCELL_ROW_66_1044 VGND VPWR sky130_fd_sc_hd__tapvpwrvgnd_1
XFILLER_22_416 VGND VGND VPWR VPWR sky130_fd_sc_hd__decap_3
XFILLER_34_265 VGND VGND VPWR VPWR sky130_fd_sc_hd__decap_3
XFILLER_62_585 VGND VGND VPWR VPWR sky130_fd_sc_hd__decap_3
XTAP_TAPCELL_ROW_17_452 VGND VPWR sky130_fd_sc_hd__tapvpwrvgnd_1
XFILLER_22_427 VGND VGND VPWR VPWR sky130_fd_sc_hd__fill_1
XFILLER_34_298 VGND VGND VPWR VPWR sky130_fd_sc_hd__decap_3
XTAP_TAPCELL_ROW_45_794 VGND VPWR sky130_fd_sc_hd__tapvpwrvgnd_1
Xclkbuf_leaf_14_clk clkload0/A VGND VGND VPWR VPWR _7371_/CLK sky130_fd_sc_hd__clkbuf_16
X_4703_ _6992_/Q _6993_/Q _5001_/A VGND VGND VPWR VPWR _4977_/A sky130_fd_sc_hd__and3_2
XFILLER_30_460 VGND VGND VPWR VPWR sky130_fd_sc_hd__decap_3
XFILLER_8_71 VGND VGND VPWR VPWR sky130_fd_sc_hd__decap_3
X_4634_ _4937_/A _4920_/A _4967_/B _4950_/A VGND VGND VPWR VPWR _4634_/Y sky130_fd_sc_hd__nand4bb_2
X_7353_ _7360_/CLK _7353_/D _6633_/Y VGND VGND VPWR VPWR _7353_/Q sky130_fd_sc_hd__dfrtp_2
Xhold601 _6927_/Q VGND VGND VPWR VPWR _6927_/D sky130_fd_sc_hd__dlygate4sd3_1
Xhold612 _6931_/Q VGND VGND VPWR VPWR _6931_/D sky130_fd_sc_hd__dlygate4sd3_1
X_4565_ _7298_/Q _4567_/B VGND VGND VPWR VPWR _7298_/D sky130_fd_sc_hd__and2_2
XFILLER_116_554 VGND VGND VPWR VPWR sky130_fd_sc_hd__decap_3
XFILLER_89_405 VGND VGND VPWR VPWR sky130_fd_sc_hd__decap_3
Xhold623 _6970_/Q VGND VGND VPWR VPWR _6970_/D sky130_fd_sc_hd__dlygate4sd3_1
Xhold634 _6892_/Q VGND VGND VPWR VPWR _6892_/D sky130_fd_sc_hd__dlygate4sd3_1
Xhold645 _6844_/Q VGND VGND VPWR VPWR _6844_/D sky130_fd_sc_hd__dlygate4sd3_1
X_6304_ _6553_/A VGND VGND VPWR VPWR _6304_/Y sky130_fd_sc_hd__inv_2
X_3516_ _5118_/A _3362_/A _5118_/D _3371_/A VGND VGND VPWR VPWR _3516_/X sky130_fd_sc_hd__a211o_2
XTAP_TAPCELL_ROW_77_1173 VGND VPWR sky130_fd_sc_hd__tapvpwrvgnd_1
XFILLER_89_438 VGND VGND VPWR VPWR sky130_fd_sc_hd__decap_3
X_7284_ clkload2/A _7284_/D _6564_/Y VGND VGND VPWR VPWR _7284_/Q sky130_fd_sc_hd__dfrtp_2
Xhold656 _6744_/Q VGND VGND VPWR VPWR _6744_/D sky130_fd_sc_hd__dlygate4sd3_1
Xhold667 _6963_/Q VGND VGND VPWR VPWR _6963_/D sky130_fd_sc_hd__dlygate4sd3_1
Xhold678 _6951_/Q VGND VGND VPWR VPWR _6951_/D sky130_fd_sc_hd__dlygate4sd3_1
XPHY_EDGE_ROW_4_Right_4 VGND VGND VPWR VPWR sky130_fd_sc_hd__decap_3
XFILLER_103_237 VGND VGND VPWR VPWR sky130_fd_sc_hd__decap_3
XFILLER_89_449 VGND VGND VPWR VPWR sky130_fd_sc_hd__decap_3
Xhold689 _6909_/Q VGND VGND VPWR VPWR _6909_/D sky130_fd_sc_hd__dlygate4sd3_1
X_3447_ _7090_/Q _3417_/X _3407_/X _7122_/Q VGND VGND VPWR VPWR _3447_/X sky130_fd_sc_hd__a22o_2
XFILLER_57_302 VGND VGND VPWR VPWR sky130_fd_sc_hd__decap_3
XFILLER_69_140 VGND VGND VPWR VPWR sky130_fd_sc_hd__decap_3
X_3378_ _3378_/A _5646_/A VGND VGND VPWR VPWR _3378_/Y sky130_fd_sc_hd__nor2_2
XFILLER_57_335 VGND VGND VPWR VPWR sky130_fd_sc_hd__fill_1
XFILLER_69_184 VGND VGND VPWR VPWR sky130_fd_sc_hd__decap_3
XFILLER_84_121 VGND VGND VPWR VPWR sky130_fd_sc_hd__decap_3
X_5117_ _5595_/B _5117_/B _3896_/Y VGND VGND VPWR VPWR _5117_/X sky130_fd_sc_hd__or3b_2
XFILLER_27_25 VGND VGND VPWR VPWR sky130_fd_sc_hd__decap_3
XFILLER_45_508 VGND VGND VPWR VPWR sky130_fd_sc_hd__decap_3
XFILLER_57_346 VGND VGND VPWR VPWR sky130_fd_sc_hd__decap_3
XFILLER_85_655 VGND VGND VPWR VPWR sky130_fd_sc_hd__decap_3
X_5048_ _5086_/A _5084_/B _4621_/X VGND VGND VPWR VPWR _5073_/B sky130_fd_sc_hd__o21bai_2
XFILLER_27_47 VGND VGND VPWR VPWR sky130_fd_sc_hd__decap_3
XFILLER_27_69 VGND VGND VPWR VPWR sky130_fd_sc_hd__decap_3
XFILLER_57_379 VGND VGND VPWR VPWR sky130_fd_sc_hd__fill_2
XFILLER_85_688 VGND VGND VPWR VPWR sky130_fd_sc_hd__decap_3
XFILLER_13_416 VGND VGND VPWR VPWR sky130_fd_sc_hd__decap_3
XFILLER_25_254 VGND VGND VPWR VPWR sky130_fd_sc_hd__decap_3
XFILLER_13_449 VGND VGND VPWR VPWR sky130_fd_sc_hd__decap_3
XFILLER_25_287 VGND VGND VPWR VPWR sky130_fd_sc_hd__decap_3
XFILLER_40_235 VGND VGND VPWR VPWR sky130_fd_sc_hd__decap_3
XFILLER_43_35 VGND VGND VPWR VPWR sky130_fd_sc_hd__fill_2
XFILLER_80_371 VGND VGND VPWR VPWR sky130_fd_sc_hd__decap_3
X_6999_ _7368_/CLK _6999_/D _6279_/Y VGND VGND VPWR VPWR _6999_/Q sky130_fd_sc_hd__dfrtp_2
XFILLER_40_268 VGND VGND VPWR VPWR sky130_fd_sc_hd__decap_3
XFILLER_43_57 VGND VGND VPWR VPWR sky130_fd_sc_hd__decap_3
XFILLER_21_460 VGND VGND VPWR VPWR sky130_fd_sc_hd__fill_1
XFILLER_111_3 VGND VGND VPWR VPWR sky130_fd_sc_hd__fill_2
XFILLER_107_543 VGND VGND VPWR VPWR sky130_fd_sc_hd__decap_3
XFILLER_4_147 VGND VGND VPWR VPWR sky130_fd_sc_hd__fill_2
XFILLER_4_158 VGND VGND VPWR VPWR sky130_fd_sc_hd__decap_3
XFILLER_107_587 VGND VGND VPWR VPWR sky130_fd_sc_hd__decap_3
XFILLER_4_29 VGND VGND VPWR VPWR sky130_fd_sc_hd__decap_3
XFILLER_108_83 VGND VGND VPWR VPWR sky130_fd_sc_hd__fill_1
XFILLER_108_94 VGND VGND VPWR VPWR sky130_fd_sc_hd__decap_3
XFILLER_68_32 VGND VGND VPWR VPWR sky130_fd_sc_hd__fill_2
XFILLER_0_353 VGND VGND VPWR VPWR sky130_fd_sc_hd__decap_3
XFILLER_68_65 VGND VGND VPWR VPWR sky130_fd_sc_hd__fill_1
XFILLER_68_76 VGND VGND VPWR VPWR sky130_fd_sc_hd__decap_3
XFILLER_48_324 VGND VGND VPWR VPWR sky130_fd_sc_hd__decap_3
XFILLER_88_471 VGND VGND VPWR VPWR sky130_fd_sc_hd__decap_3
XFILLER_75_154 VGND VGND VPWR VPWR sky130_fd_sc_hd__fill_2
XFILLER_63_305 VGND VGND VPWR VPWR sky130_fd_sc_hd__decap_3
XFILLER_75_187 VGND VGND VPWR VPWR sky130_fd_sc_hd__decap_3
XFILLER_63_349 VGND VGND VPWR VPWR sky130_fd_sc_hd__decap_3
XFILLER_84_97 VGND VGND VPWR VPWR sky130_fd_sc_hd__decap_3
Xplace327 _3590_/A VGND VGND VPWR VPWR _4460_/A sky130_fd_sc_hd__buf_2
Xplace316 _5274_/S VGND VGND VPWR VPWR _5292_/S sky130_fd_sc_hd__buf_2
Xplace305 _3635_/B VGND VGND VPWR VPWR _5033_/B2 sky130_fd_sc_hd__buf_2
XFILLER_16_265 VGND VGND VPWR VPWR sky130_fd_sc_hd__decap_3
Xplace349 _4337_/B VGND VGND VPWR VPWR _4270_/B sky130_fd_sc_hd__buf_2
Xplace338 _4340_/A2 VGND VGND VPWR VPWR _4262_/A2 sky130_fd_sc_hd__buf_2
XFILLER_16_298 VGND VGND VPWR VPWR sky130_fd_sc_hd__decap_3
XFILLER_71_393 VGND VGND VPWR VPWR sky130_fd_sc_hd__decap_3
XTAP_TAPCELL_ROW_14_422 VGND VPWR sky130_fd_sc_hd__tapvpwrvgnd_1
XFILLER_31_268 VGND VGND VPWR VPWR sky130_fd_sc_hd__decap_3
XTAP_TAPCELL_ROW_42_753 VGND VPWR sky130_fd_sc_hd__tapvpwrvgnd_1
XFILLER_12_460 VGND VGND VPWR VPWR sky130_fd_sc_hd__decap_3
XFILLER_12_471 VGND VGND VPWR VPWR sky130_fd_sc_hd__fill_1
XFILLER_33_90 VGND VGND VPWR VPWR sky130_fd_sc_hd__decap_3
XFILLER_76_6 VGND VGND VPWR VPWR sky130_fd_sc_hd__decap_3
XFILLER_8_453 VGND VGND VPWR VPWR sky130_fd_sc_hd__fill_2
X_4350_ _7065_/Q _4305_/B _4460_/A VGND VGND VPWR VPWR _4367_/B sky130_fd_sc_hd__o21a_2
XTAP_TAPCELL_ROW_113_1605 VGND VPWR sky130_fd_sc_hd__tapvpwrvgnd_1
X_3301_ _3327_/A _3353_/A VGND VGND VPWR VPWR _3519_/B sky130_fd_sc_hd__nand2_4
X_4281_ _7254_/Q _4601_/S _4278_/X _4280_/X VGND VGND VPWR VPWR _4281_/X sky130_fd_sc_hd__a211o_2
XFILLER_67_600 VGND VGND VPWR VPWR sky130_fd_sc_hd__decap_3
Xclkbuf_leaf_3_clk clkbuf_leaf_9_clk/A VGND VGND VPWR VPWR _7364_/CLK sky130_fd_sc_hd__clkbuf_16
XFILLER_98_268 VGND VGND VPWR VPWR sky130_fd_sc_hd__decap_3
XFILLER_39_302 VGND VGND VPWR VPWR sky130_fd_sc_hd__decap_3
XFILLER_79_482 VGND VGND VPWR VPWR sky130_fd_sc_hd__decap_3
XFILLER_27_508 VGND VGND VPWR VPWR sky130_fd_sc_hd__decap_3
XFILLER_39_357 VGND VGND VPWR VPWR sky130_fd_sc_hd__decap_3
XFILLER_67_655 VGND VGND VPWR VPWR sky130_fd_sc_hd__fill_2
XFILLER_94_430 VGND VGND VPWR VPWR sky130_fd_sc_hd__decap_3
XFILLER_54_305 VGND VGND VPWR VPWR sky130_fd_sc_hd__decap_3
XFILLER_66_165 VGND VGND VPWR VPWR sky130_fd_sc_hd__decap_3
XFILLER_54_338 VGND VGND VPWR VPWR sky130_fd_sc_hd__decap_3
XFILLER_82_658 VGND VGND VPWR VPWR sky130_fd_sc_hd__decap_3
X_6922_ _7351_/CLK _6922_/D VGND VGND VPWR VPWR _6922_/Q sky130_fd_sc_hd__dfxtp_2
XFILLER_81_157 VGND VGND VPWR VPWR sky130_fd_sc_hd__decap_3
X_6853_ _6909_/CLK _6853_/D VGND VGND VPWR VPWR _6853_/Q sky130_fd_sc_hd__dfxtp_2
XFILLER_22_224 VGND VGND VPWR VPWR sky130_fd_sc_hd__decap_3
Xfanout17 _6536_/A VGND VGND VPWR VPWR _6347_/A sky130_fd_sc_hd__buf_2
Xfanout28 _6600_/A VGND VGND VPWR VPWR _6664_/A sky130_fd_sc_hd__clkdlybuf4s25_1
XFILLER_22_268 VGND VGND VPWR VPWR sky130_fd_sc_hd__decap_3
XFILLER_50_544 VGND VGND VPWR VPWR sky130_fd_sc_hd__fill_2
Xfanout39 wire582/X VGND VGND VPWR VPWR wire579/A sky130_fd_sc_hd__buf_1
X_6784_ _6972_/CLK _6784_/D VGND VGND VPWR VPWR _6784_/Q sky130_fd_sc_hd__dfxtp_2
X_3996_ _7344_/Q _4534_/A0 _3996_/S VGND VGND VPWR VPWR _7344_/D sky130_fd_sc_hd__mux2_2
XFILLER_10_419 VGND VGND VPWR VPWR sky130_fd_sc_hd__fill_1
XFILLER_13_38 VGND VGND VPWR VPWR sky130_fd_sc_hd__decap_3
X_5735_ _7373_/Q hold926/X _5737_/S VGND VGND VPWR VPWR _6717_/D sky130_fd_sc_hd__mux2_2
X_5666_ _5666_/A _5666_/B VGND VGND VPWR VPWR _5668_/B sky130_fd_sc_hd__or2_2
XTAP_TAPCELL_ROW_79_1202 VGND VPWR sky130_fd_sc_hd__tapvpwrvgnd_1
XFILLER_108_318 VGND VGND VPWR VPWR sky130_fd_sc_hd__decap_3
X_7405_ _7406_/CLK _7405_/D _6685_/Y VGND VGND VPWR VPWR _7405_/Q sky130_fd_sc_hd__dfrtp_2
X_4617_ _5114_/B _4617_/B _4617_/C VGND VGND VPWR VPWR _5099_/A sky130_fd_sc_hd__or3_4
XFILLER_116_340 VGND VGND VPWR VPWR sky130_fd_sc_hd__fill_2
X_5597_ hold964/X _5587_/B _5154_/Y VGND VGND VPWR VPWR _7029_/D sky130_fd_sc_hd__a21o_2
XFILLER_116_362 VGND VGND VPWR VPWR sky130_fd_sc_hd__fill_2
X_7336_ _7365_/CLK _7336_/D _6616_/Y VGND VGND VPWR VPWR _7336_/Q sky130_fd_sc_hd__dfrtp_2
X_4548_ _7306_/Q _4569_/B VGND VGND VPWR VPWR _7306_/D sky130_fd_sc_hd__and2_2
XFILLER_89_246 VGND VGND VPWR VPWR sky130_fd_sc_hd__decap_3
X_7267_ _7362_/CLK _7267_/D _6547_/Y VGND VGND VPWR VPWR _7267_/Q sky130_fd_sc_hd__dfrtp_2
XFILLER_38_35 VGND VGND VPWR VPWR sky130_fd_sc_hd__decap_3
XFILLER_57_110 VGND VGND VPWR VPWR sky130_fd_sc_hd__fill_2
X_7198_ _7198_/CLK _7198_/D _6478_/Y VGND VGND VPWR VPWR _7198_/Q sky130_fd_sc_hd__dfrtp_2
XFILLER_38_57 VGND VGND VPWR VPWR sky130_fd_sc_hd__decap_3
XFILLER_85_441 VGND VGND VPWR VPWR sky130_fd_sc_hd__decap_3
XFILLER_85_452 VGND VGND VPWR VPWR sky130_fd_sc_hd__decap_3
XFILLER_97_290 VGND VGND VPWR VPWR sky130_fd_sc_hd__decap_3
Xhold1120 _7170_/Q VGND VGND VPWR VPWR _5321_/A0 sky130_fd_sc_hd__dlygate4sd3_1
Xhold1131 _7155_/Q VGND VGND VPWR VPWR _5352_/A0 sky130_fd_sc_hd__dlygate4sd3_1
Xhold1142 _7228_/Q VGND VGND VPWR VPWR _5200_/A sky130_fd_sc_hd__dlygate4sd3_1
XFILLER_45_305 VGND VGND VPWR VPWR sky130_fd_sc_hd__fill_1
XFILLER_57_165 VGND VGND VPWR VPWR sky130_fd_sc_hd__decap_3
Xhold1153 _7133_/Q VGND VGND VPWR VPWR _5400_/A0 sky130_fd_sc_hd__dlygate4sd3_1
Xhold1164 _7148_/Q VGND VGND VPWR VPWR _5369_/A0 sky130_fd_sc_hd__dlygate4sd3_1
Xhold1175 _7304_/Q VGND VGND VPWR VPWR _4552_/A sky130_fd_sc_hd__dlygate4sd3_1
XPHY_EDGE_ROW_79_Right_79 VGND VGND VPWR VPWR sky130_fd_sc_hd__decap_3
XFILLER_45_349 VGND VGND VPWR VPWR sky130_fd_sc_hd__decap_3
XFILLER_54_12 VGND VGND VPWR VPWR sky130_fd_sc_hd__decap_3
XFILLER_57_198 VGND VGND VPWR VPWR sky130_fd_sc_hd__decap_3
Xhold1186 _7169_/Q VGND VGND VPWR VPWR _5323_/A0 sky130_fd_sc_hd__dlygate4sd3_1
Xhold1197 _7248_/Q VGND VGND VPWR VPWR _5157_/A0 sky130_fd_sc_hd__dlygate4sd3_1
XFILLER_54_56 VGND VGND VPWR VPWR sky130_fd_sc_hd__decap_3
XFILLER_41_511 VGND VGND VPWR VPWR sky130_fd_sc_hd__decap_3
XFILLER_53_382 VGND VGND VPWR VPWR sky130_fd_sc_hd__fill_1
XFILLER_53_393 VGND VGND VPWR VPWR sky130_fd_sc_hd__fill_1
XFILLER_81_691 VGND VGND VPWR VPWR sky130_fd_sc_hd__fill_1
XFILLER_80_190 VGND VGND VPWR VPWR sky130_fd_sc_hd__decap_3
XFILLER_110_73 VGND VGND VPWR VPWR sky130_fd_sc_hd__decap_3
XFILLER_13_268 VGND VGND VPWR VPWR sky130_fd_sc_hd__decap_3
XFILLER_70_44 VGND VGND VPWR VPWR sky130_fd_sc_hd__fill_2
XFILLER_9_228 VGND VGND VPWR VPWR sky130_fd_sc_hd__decap_3
XFILLER_9_217 VGND VGND VPWR VPWR sky130_fd_sc_hd__decap_3
XFILLER_21_290 VGND VGND VPWR VPWR sky130_fd_sc_hd__decap_3
XFILLER_70_66 VGND VGND VPWR VPWR sky130_fd_sc_hd__fill_1
XFILLER_70_88 VGND VGND VPWR VPWR sky130_fd_sc_hd__fill_2
XFILLER_70_99 VGND VGND VPWR VPWR sky130_fd_sc_hd__fill_1
XPHY_EDGE_ROW_88_Right_88 VGND VGND VPWR VPWR sky130_fd_sc_hd__decap_3
XFILLER_107_340 VGND VGND VPWR VPWR sky130_fd_sc_hd__decap_3
XFILLER_5_423 VGND VGND VPWR VPWR sky130_fd_sc_hd__decap_3
XFILLER_107_373 VGND VGND VPWR VPWR sky130_fd_sc_hd__decap_3
XFILLER_79_31 VGND VGND VPWR VPWR sky130_fd_sc_hd__decap_3
XFILLER_79_42 VGND VGND VPWR VPWR sky130_fd_sc_hd__decap_3
XFILLER_1_662 VGND VGND VPWR VPWR sky130_fd_sc_hd__fill_2
XFILLER_68_419 VGND VGND VPWR VPWR sky130_fd_sc_hd__fill_1
XFILLER_95_205 VGND VGND VPWR VPWR sky130_fd_sc_hd__decap_3
XFILLER_0_161 VGND VGND VPWR VPWR sky130_fd_sc_hd__decap_3
XFILLER_0_172 VGND VGND VPWR VPWR sky130_fd_sc_hd__decap_3
XFILLER_1_673 VGND VGND VPWR VPWR sky130_fd_sc_hd__fill_2
XFILLER_95_30 VGND VGND VPWR VPWR sky130_fd_sc_hd__decap_3
XFILLER_76_430 VGND VGND VPWR VPWR sky130_fd_sc_hd__decap_3
XFILLER_95_249 VGND VGND VPWR VPWR sky130_fd_sc_hd__decap_3
XFILLER_95_63 VGND VGND VPWR VPWR sky130_fd_sc_hd__decap_3
XPHY_EDGE_ROW_97_Right_97 VGND VGND VPWR VPWR sky130_fd_sc_hd__decap_3
XFILLER_36_327 VGND VGND VPWR VPWR sky130_fd_sc_hd__decap_3
XFILLER_76_463 VGND VGND VPWR VPWR sky130_fd_sc_hd__decap_3
XFILLER_91_411 VGND VGND VPWR VPWR sky130_fd_sc_hd__fill_1
XTAP_TAPCELL_ROW_47_812 VGND VPWR sky130_fd_sc_hd__tapvpwrvgnd_1
XFILLER_91_455 VGND VGND VPWR VPWR sky130_fd_sc_hd__decap_3
XFILLER_51_308 VGND VGND VPWR VPWR sky130_fd_sc_hd__decap_3
XFILLER_63_157 VGND VGND VPWR VPWR sky130_fd_sc_hd__fill_2
XFILLER_32_533 VGND VGND VPWR VPWR sky130_fd_sc_hd__fill_1
XFILLER_44_371 VGND VGND VPWR VPWR sky130_fd_sc_hd__decap_3
XTAP_TAPCELL_ROW_63_1003 VGND VPWR sky130_fd_sc_hd__tapvpwrvgnd_1
XTAP_TAPCELL_ROW_27_580 VGND VPWR sky130_fd_sc_hd__tapvpwrvgnd_1
XFILLER_71_190 VGND VGND VPWR VPWR sky130_fd_sc_hd__decap_3
X_3850_ _6810_/Q _5660_/B _3852_/B1 _6820_/Q VGND VGND VPWR VPWR _3850_/X sky130_fd_sc_hd__a22o_2
XPHY_EDGE_ROW_4_Left_121 VGND VGND VPWR VPWR sky130_fd_sc_hd__decap_3
XFILLER_32_599 VGND VGND VPWR VPWR sky130_fd_sc_hd__decap_3
X_3781_ _6949_/Q _5660_/B _3852_/B1 _6961_/Q _3780_/X VGND VGND VPWR VPWR _3781_/X
+ sky130_fd_sc_hd__a221o_2
XFILLER_74_3 VGND VGND VPWR VPWR sky130_fd_sc_hd__decap_3
XFILLER_8_250 VGND VGND VPWR VPWR sky130_fd_sc_hd__fill_2
Xoutput536 _6997_/Q VGND VGND VPWR VPWR pc_out[20] sky130_fd_sc_hd__clkdlybuf4s25_1
Xoutput525 _6987_/Q VGND VGND VPWR VPWR pc_out[10] sky130_fd_sc_hd__clkdlybuf4s25_1
Xoutput514 _4671_/B VGND VGND VPWR VPWR instruction_out[28] sky130_fd_sc_hd__clkdlybuf4s25_1
Xoutput503 _3394_/A VGND VGND VPWR VPWR instruction_out[16] sky130_fd_sc_hd__clkdlybuf4s25_1
X_4402_ _7082_/Q _4432_/A2 _4432_/B1 _4401_/X VGND VGND VPWR VPWR _4403_/A sky130_fd_sc_hd__o211a_2
XFILLER_99_511 VGND VGND VPWR VPWR sky130_fd_sc_hd__decap_3
XFILLER_99_500 VGND VGND VPWR VPWR sky130_fd_sc_hd__decap_3
XFILLER_113_332 VGND VGND VPWR VPWR sky130_fd_sc_hd__decap_3
X_7121_ clkload7/A _7121_/D _6401_/Y VGND VGND VPWR VPWR _7121_/Q sky130_fd_sc_hd__dfrtp_2
Xoutput547 _7007_/Q VGND VGND VPWR VPWR pc_out[30] sky130_fd_sc_hd__clkdlybuf4s25_1
X_4333_ _7127_/Q _3407_/X _4332_/X VGND VGND VPWR VPWR _4336_/A sky130_fd_sc_hd__a21o_2
XTAP_TAPCELL_ROW_74_1143 VGND VPWR sky130_fd_sc_hd__tapvpwrvgnd_1
XFILLER_99_555 VGND VGND VPWR VPWR sky130_fd_sc_hd__decap_3
XFILLER_101_505 VGND VGND VPWR VPWR sky130_fd_sc_hd__decap_3
XFILLER_113_343 VGND VGND VPWR VPWR sky130_fd_sc_hd__decap_3
XFILLER_59_408 VGND VGND VPWR VPWR sky130_fd_sc_hd__decap_3
X_7052_ _7368_/CLK _7052_/D _6332_/Y VGND VGND VPWR VPWR _7052_/Q sky130_fd_sc_hd__dfrtp_2
X_4264_ _4264_/A _4264_/B VGND VGND VPWR VPWR _4376_/B sky130_fd_sc_hd__nor2_2
XFILLER_113_376 VGND VGND VPWR VPWR sky130_fd_sc_hd__decap_3
XFILLER_86_227 VGND VGND VPWR VPWR sky130_fd_sc_hd__decap_3
XFILLER_99_599 VGND VGND VPWR VPWR sky130_fd_sc_hd__fill_2
XFILLER_67_430 VGND VGND VPWR VPWR sky130_fd_sc_hd__decap_3
X_4195_ _7135_/Q _4195_/A2 _4267_/B1 _7167_/Q VGND VGND VPWR VPWR _4195_/X sky130_fd_sc_hd__a22o_2
XFILLER_27_305 VGND VGND VPWR VPWR sky130_fd_sc_hd__decap_3
XFILLER_39_154 VGND VGND VPWR VPWR sky130_fd_sc_hd__fill_1
XFILLER_55_614 VGND VGND VPWR VPWR sky130_fd_sc_hd__fill_2
XFILLER_67_463 VGND VGND VPWR VPWR sky130_fd_sc_hd__decap_3
XFILLER_82_400 VGND VGND VPWR VPWR sky130_fd_sc_hd__decap_3
XFILLER_27_349 VGND VGND VPWR VPWR sky130_fd_sc_hd__decap_3
XFILLER_54_124 VGND VGND VPWR VPWR sky130_fd_sc_hd__decap_3
XFILLER_67_496 VGND VGND VPWR VPWR sky130_fd_sc_hd__decap_3
XFILLER_82_433 VGND VGND VPWR VPWR sky130_fd_sc_hd__decap_3
XFILLER_94_293 VGND VGND VPWR VPWR sky130_fd_sc_hd__decap_3
XFILLER_82_466 VGND VGND VPWR VPWR sky130_fd_sc_hd__decap_3
XFILLER_82_477 VGND VGND VPWR VPWR sky130_fd_sc_hd__decap_3
X_6905_ _6936_/CLK _6905_/D VGND VGND VPWR VPWR _6905_/Q sky130_fd_sc_hd__dfxtp_2
XFILLER_35_360 VGND VGND VPWR VPWR sky130_fd_sc_hd__decap_3
XTAP_TAPCELL_ROW_85_1272 VGND VPWR sky130_fd_sc_hd__tapvpwrvgnd_1
XFILLER_24_26 VGND VGND VPWR VPWR sky130_fd_sc_hd__fill_2
XFILLER_35_393 VGND VGND VPWR VPWR sky130_fd_sc_hd__decap_3
XFILLER_50_330 VGND VGND VPWR VPWR sky130_fd_sc_hd__decap_3
X_6836_ _6972_/CLK _6836_/D VGND VGND VPWR VPWR _6836_/Q sky130_fd_sc_hd__dfxtp_2
XPHY_EDGE_ROW_59_Left_176 VGND VGND VPWR VPWR sky130_fd_sc_hd__decap_3
XFILLER_10_205 VGND VGND VPWR VPWR sky130_fd_sc_hd__decap_3
XFILLER_23_588 VGND VGND VPWR VPWR sky130_fd_sc_hd__decap_3
XFILLER_24_59 VGND VGND VPWR VPWR sky130_fd_sc_hd__decap_3
XFILLER_50_363 VGND VGND VPWR VPWR sky130_fd_sc_hd__fill_1
X_6767_ _7351_/CLK _6767_/D VGND VGND VPWR VPWR _6767_/Q sky130_fd_sc_hd__dfxtp_2
XFILLER_50_396 VGND VGND VPWR VPWR sky130_fd_sc_hd__decap_3
X_3979_ _7351_/Q _4520_/A0 _3989_/S VGND VGND VPWR VPWR _7351_/D sky130_fd_sc_hd__mux2_2
XFILLER_6_209 VGND VGND VPWR VPWR sky130_fd_sc_hd__decap_3
X_6698_ _7383_/CLK _6698_/D VGND VGND VPWR VPWR _6698_/Q sky130_fd_sc_hd__dfxtp_2
XFILLER_108_148 VGND VGND VPWR VPWR sky130_fd_sc_hd__fill_2
XFILLER_40_47 VGND VGND VPWR VPWR sky130_fd_sc_hd__decap_3
X_5649_ _5649_/A VGND VGND VPWR VPWR _5649_/X sky130_fd_sc_hd__buf_1
XFILLER_104_321 VGND VGND VPWR VPWR sky130_fd_sc_hd__decap_3
XFILLER_116_181 VGND VGND VPWR VPWR sky130_fd_sc_hd__fill_1
XFILLER_2_426 VGND VGND VPWR VPWR sky130_fd_sc_hd__decap_3
XFILLER_6_6 VGND VGND VPWR VPWR sky130_fd_sc_hd__decap_3
X_7319_ clkload2/A _7319_/D _6599_/Y VGND VGND VPWR VPWR _7319_/Q sky130_fd_sc_hd__dfrtp_2
XPHY_EDGE_ROW_68_Left_185 VGND VGND VPWR VPWR sky130_fd_sc_hd__decap_3
XFILLER_104_354 VGND VGND VPWR VPWR sky130_fd_sc_hd__decap_3
XFILLER_104_365 VGND VGND VPWR VPWR sky130_fd_sc_hd__decap_3
XFILLER_104_376 VGND VGND VPWR VPWR sky130_fd_sc_hd__decap_3
XFILLER_58_430 VGND VGND VPWR VPWR sky130_fd_sc_hd__fill_1
XFILLER_77_249 VGND VGND VPWR VPWR sky130_fd_sc_hd__decap_3
XFILLER_105_84 VGND VGND VPWR VPWR sky130_fd_sc_hd__decap_3
XFILLER_46_625 VGND VGND VPWR VPWR sky130_fd_sc_hd__fill_2
XFILLER_58_463 VGND VGND VPWR VPWR sky130_fd_sc_hd__decap_3
XFILLER_45_113 VGND VGND VPWR VPWR sky130_fd_sc_hd__decap_3
XFILLER_65_44 VGND VGND VPWR VPWR sky130_fd_sc_hd__decap_3
XFILLER_65_66 VGND VGND VPWR VPWR sky130_fd_sc_hd__fill_1
XFILLER_73_422 VGND VGND VPWR VPWR sky130_fd_sc_hd__decap_3
XFILLER_85_293 VGND VGND VPWR VPWR sky130_fd_sc_hd__decap_3
XFILLER_45_146 VGND VGND VPWR VPWR sky130_fd_sc_hd__decap_3
XFILLER_61_606 VGND VGND VPWR VPWR sky130_fd_sc_hd__fill_1
XFILLER_61_617 VGND VGND VPWR VPWR sky130_fd_sc_hd__decap_3
XFILLER_73_466 VGND VGND VPWR VPWR sky130_fd_sc_hd__decap_3
XFILLER_14_500 VGND VGND VPWR VPWR sky130_fd_sc_hd__fill_1
XFILLER_26_371 VGND VGND VPWR VPWR sky130_fd_sc_hd__decap_3
XFILLER_45_179 VGND VGND VPWR VPWR sky130_fd_sc_hd__decap_3
XFILLER_73_499 VGND VGND VPWR VPWR sky130_fd_sc_hd__decap_3
XPHY_EDGE_ROW_77_Left_194 VGND VGND VPWR VPWR sky130_fd_sc_hd__decap_3
XFILLER_14_533 VGND VGND VPWR VPWR sky130_fd_sc_hd__fill_1
XFILLER_14_599 VGND VGND VPWR VPWR sky130_fd_sc_hd__decap_3
XTAP_TAPCELL_ROW_52_881 VGND VPWR sky130_fd_sc_hd__tapvpwrvgnd_1
XTAP_TAPCELL_ROW_52_870 VGND VPWR sky130_fd_sc_hd__tapvpwrvgnd_1
XFILLER_41_396 VGND VGND VPWR VPWR sky130_fd_sc_hd__decap_3
XFILLER_5_220 VGND VGND VPWR VPWR sky130_fd_sc_hd__fill_1
XFILLER_114_107 VGND VGND VPWR VPWR sky130_fd_sc_hd__decap_3
XFILLER_5_242 VGND VGND VPWR VPWR sky130_fd_sc_hd__decap_3
XFILLER_30_91 VGND VGND VPWR VPWR sky130_fd_sc_hd__decap_3
XFILLER_68_227 VGND VGND VPWR VPWR sky130_fd_sc_hd__decap_3
XFILLER_96_536 VGND VGND VPWR VPWR sky130_fd_sc_hd__decap_3
XFILLER_110_346 VGND VGND VPWR VPWR sky130_fd_sc_hd__decap_3
XFILLER_68_249 VGND VGND VPWR VPWR sky130_fd_sc_hd__decap_3
XFILLER_49_452 VGND VGND VPWR VPWR sky130_fd_sc_hd__fill_2
XFILLER_64_400 VGND VGND VPWR VPWR sky130_fd_sc_hd__decap_3
XFILLER_83_208 VGND VGND VPWR VPWR sky130_fd_sc_hd__decap_3
XFILLER_36_135 VGND VGND VPWR VPWR sky130_fd_sc_hd__decap_3
XFILLER_76_282 VGND VGND VPWR VPWR sky130_fd_sc_hd__decap_3
XTAP_TAPCELL_ROW_108_1548 VGND VPWR sky130_fd_sc_hd__tapvpwrvgnd_1
XFILLER_64_477 VGND VGND VPWR VPWR sky130_fd_sc_hd__decap_3
XFILLER_36_179 VGND VGND VPWR VPWR sky130_fd_sc_hd__decap_3
XFILLER_51_116 VGND VGND VPWR VPWR sky130_fd_sc_hd__decap_3
X_4951_ _4949_/Y _4950_/Y _4918_/B VGND VGND VPWR VPWR _4951_/Y sky130_fd_sc_hd__a21oi_2
XFILLER_17_393 VGND VGND VPWR VPWR sky130_fd_sc_hd__decap_3
XFILLER_44_190 VGND VGND VPWR VPWR sky130_fd_sc_hd__decap_3
X_4882_ _4882_/A _4882_/B VGND VGND VPWR VPWR _6998_/D sky130_fd_sc_hd__and2_2
X_3902_ _6918_/Q _3926_/A2 _3925_/B1 _6870_/Q VGND VGND VPWR VPWR _3902_/X sky130_fd_sc_hd__a22o_2
XFILLER_20_503 VGND VGND VPWR VPWR sky130_fd_sc_hd__decap_3
XFILLER_32_374 VGND VGND VPWR VPWR sky130_fd_sc_hd__decap_3
X_6621_ _6682_/A VGND VGND VPWR VPWR _6621_/Y sky130_fd_sc_hd__inv_2
X_3833_ _3833_/A0 _3832_/X _3864_/S VGND VGND VPWR VPWR _7388_/D sky130_fd_sc_hd__mux2_2
X_6552_ _6584_/A VGND VGND VPWR VPWR _6552_/Y sky130_fd_sc_hd__inv_2
X_3764_ _6706_/Q _6796_/Q _6884_/Q _6932_/Q _3991_/B _3665_/B VGND VGND VPWR VPWR
+ _3764_/X sky130_fd_sc_hd__mux4_2
X_6483_ _6522_/A VGND VGND VPWR VPWR _6483_/Y sky130_fd_sc_hd__inv_2
X_3695_ _6714_/Q _3863_/A2 _3858_/B1 _6892_/Q VGND VGND VPWR VPWR _3695_/X sky130_fd_sc_hd__a22o_2
XFILLER_87_503 VGND VGND VPWR VPWR sky130_fd_sc_hd__fill_1
X_7104_ _7294_/CLK _7104_/D _6384_/Y VGND VGND VPWR VPWR _7104_/Q sky130_fd_sc_hd__dfrtp_2
X_5365_ _5365_/A0 _4716_/X _5383_/S VGND VGND VPWR VPWR _7150_/D sky130_fd_sc_hd__mux2_4
XFILLER_101_302 VGND VGND VPWR VPWR sky130_fd_sc_hd__decap_3
XFILLER_113_151 VGND VGND VPWR VPWR sky130_fd_sc_hd__decap_3
X_5296_ _5296_/A0 _4716_/X _5325_/S VGND VGND VPWR VPWR _7182_/D sky130_fd_sc_hd__mux2_4
X_4316_ _7226_/Q _4349_/B1 _4348_/B1 _7130_/Q VGND VGND VPWR VPWR _4316_/X sky130_fd_sc_hd__a22o_2
XFILLER_99_385 VGND VGND VPWR VPWR sky130_fd_sc_hd__decap_3
XFILLER_101_357 VGND VGND VPWR VPWR sky130_fd_sc_hd__decap_3
XFILLER_113_195 VGND VGND VPWR VPWR sky130_fd_sc_hd__decap_3
XFILLER_19_26 VGND VGND VPWR VPWR sky130_fd_sc_hd__decap_3
XFILLER_19_37 VGND VGND VPWR VPWR sky130_fd_sc_hd__decap_3
XFILLER_59_249 VGND VGND VPWR VPWR sky130_fd_sc_hd__decap_3
X_7035_ _7381_/CLK _7035_/D _6315_/Y VGND VGND VPWR VPWR _7035_/Q sky130_fd_sc_hd__dfrtp_2
X_4247_ _7261_/Q _4356_/A2 _3964_/S _7325_/Q _4246_/X VGND VGND VPWR VPWR _4248_/C
+ sky130_fd_sc_hd__a221o_2
X_4178_ _7264_/Q _4356_/A2 _4177_/X VGND VGND VPWR VPWR _4178_/Y sky130_fd_sc_hd__a21oi_2
XTAP_TAPCELL_ROW_87_1301 VGND VPWR sky130_fd_sc_hd__tapvpwrvgnd_1
XFILLER_27_113 VGND VGND VPWR VPWR sky130_fd_sc_hd__decap_3
XFILLER_55_433 VGND VGND VPWR VPWR sky130_fd_sc_hd__decap_3
XFILLER_67_293 VGND VGND VPWR VPWR sky130_fd_sc_hd__decap_3
XFILLER_27_146 VGND VGND VPWR VPWR sky130_fd_sc_hd__decap_3
XFILLER_55_455 VGND VGND VPWR VPWR sky130_fd_sc_hd__decap_3
XFILLER_70_403 VGND VGND VPWR VPWR sky130_fd_sc_hd__decap_3
XFILLER_82_241 VGND VGND VPWR VPWR sky130_fd_sc_hd__decap_3
XTAP_TAPCELL_ROW_2_278 VGND VPWR sky130_fd_sc_hd__tapvpwrvgnd_1
XFILLER_35_36 VGND VGND VPWR VPWR sky130_fd_sc_hd__decap_3
XFILLER_36_691 VGND VGND VPWR VPWR sky130_fd_sc_hd__fill_1
XFILLER_42_127 VGND VGND VPWR VPWR sky130_fd_sc_hd__decap_3
XFILLER_55_488 VGND VGND VPWR VPWR sky130_fd_sc_hd__fill_1
XFILLER_55_499 VGND VGND VPWR VPWR sky130_fd_sc_hd__fill_2
XFILLER_70_447 VGND VGND VPWR VPWR sky130_fd_sc_hd__decap_3
XFILLER_23_363 VGND VGND VPWR VPWR sky130_fd_sc_hd__decap_3
X_6819_ _6936_/CLK _6819_/D VGND VGND VPWR VPWR _6819_/Q sky130_fd_sc_hd__dfxtp_2
XFILLER_23_385 VGND VGND VPWR VPWR sky130_fd_sc_hd__decap_3
XFILLER_23_396 VGND VGND VPWR VPWR sky130_fd_sc_hd__decap_3
XFILLER_50_171 VGND VGND VPWR VPWR sky130_fd_sc_hd__decap_3
XFILLER_109_402 VGND VGND VPWR VPWR sky130_fd_sc_hd__decap_3
XTAP_TAPCELL_ROW_98_1430 VGND VPWR sky130_fd_sc_hd__tapvpwrvgnd_1
XFILLER_109_446 VGND VGND VPWR VPWR sky130_fd_sc_hd__fill_2
XFILLER_105_641 VGND VGND VPWR VPWR sky130_fd_sc_hd__decap_3
XFILLER_4_3 VGND VGND VPWR VPWR sky130_fd_sc_hd__decap_3
XFILLER_78_525 VGND VGND VPWR VPWR sky130_fd_sc_hd__decap_3
XFILLER_104_195 VGND VGND VPWR VPWR sky130_fd_sc_hd__fill_1
XFILLER_116_83 VGND VGND VPWR VPWR sky130_fd_sc_hd__fill_1
XFILLER_116_94 VGND VGND VPWR VPWR sky130_fd_sc_hd__decap_3
XFILLER_76_32 VGND VGND VPWR VPWR sky130_fd_sc_hd__decap_3
XFILLER_65_208 VGND VGND VPWR VPWR sky130_fd_sc_hd__decap_3
XFILLER_76_65 VGND VGND VPWR VPWR sky130_fd_sc_hd__decap_3
XFILLER_58_282 VGND VGND VPWR VPWR sky130_fd_sc_hd__decap_3
XFILLER_46_477 VGND VGND VPWR VPWR sky130_fd_sc_hd__decap_3
Xplace75 _5657_/B VGND VGND VPWR VPWR place75/X sky130_fd_sc_hd__buf_2
XTAP_TAPCELL_ROW_57_940 VGND VPWR sky130_fd_sc_hd__tapvpwrvgnd_1
XPHY_EDGE_ROW_85_Left_202 VGND VGND VPWR VPWR sky130_fd_sc_hd__decap_3
XFILLER_33_116 VGND VGND VPWR VPWR sky130_fd_sc_hd__decap_3
XFILLER_14_330 VGND VGND VPWR VPWR sky130_fd_sc_hd__decap_3
XFILLER_33_138 VGND VGND VPWR VPWR sky130_fd_sc_hd__decap_3
XFILLER_61_458 VGND VGND VPWR VPWR sky130_fd_sc_hd__decap_3
XFILLER_92_64 VGND VGND VPWR VPWR sky130_fd_sc_hd__decap_3
XFILLER_92_97 VGND VGND VPWR VPWR sky130_fd_sc_hd__decap_3
XTAP_TAPCELL_ROW_103_1489 VGND VPWR sky130_fd_sc_hd__tapvpwrvgnd_1
XPHY_EDGE_ROW_94_Left_211 VGND VGND VPWR VPWR sky130_fd_sc_hd__decap_3
XFILLER_41_90 VGND VGND VPWR VPWR sky130_fd_sc_hd__fill_2
X_3480_ _7088_/Q _4351_/A2 _3407_/X _7120_/Q VGND VGND VPWR VPWR _3482_/B sky130_fd_sc_hd__a22o_2
XFILLER_115_449 VGND VGND VPWR VPWR sky130_fd_sc_hd__decap_3
XTAP_TAPCELL_ROW_71_1102 VGND VPWR sky130_fd_sc_hd__tapvpwrvgnd_1
XFILLER_37_3 VGND VGND VPWR VPWR sky130_fd_sc_hd__decap_3
XFILLER_69_514 VGND VGND VPWR VPWR sky130_fd_sc_hd__decap_3
X_5150_ _3501_/X _3618_/X _5145_/X _5149_/Y VGND VGND VPWR VPWR _5659_/B sky130_fd_sc_hd__a31o_2
XFILLER_111_655 VGND VGND VPWR VPWR sky130_fd_sc_hd__decap_3
XFILLER_96_333 VGND VGND VPWR VPWR sky130_fd_sc_hd__decap_3
X_4101_ _7141_/Q _4190_/B1 _4100_/X VGND VGND VPWR VPWR _4141_/A sky130_fd_sc_hd__a21oi_2
XFILLER_110_154 VGND VGND VPWR VPWR sky130_fd_sc_hd__fill_2
XFILLER_84_528 VGND VGND VPWR VPWR sky130_fd_sc_hd__decap_3
XFILLER_96_377 VGND VGND VPWR VPWR sky130_fd_sc_hd__decap_3
X_4032_ _7246_/Q _4433_/B _3943_/S _7214_/Q VGND VGND VPWR VPWR _4032_/X sky130_fd_sc_hd__a22o_2
XFILLER_49_293 VGND VGND VPWR VPWR sky130_fd_sc_hd__decap_3
XFILLER_77_580 VGND VGND VPWR VPWR sky130_fd_sc_hd__decap_3
XFILLER_84_539 VGND VGND VPWR VPWR sky130_fd_sc_hd__decap_3
XFILLER_37_455 VGND VGND VPWR VPWR sky130_fd_sc_hd__decap_3
XFILLER_24_116 VGND VGND VPWR VPWR sky130_fd_sc_hd__decap_3
XFILLER_25_617 VGND VGND VPWR VPWR sky130_fd_sc_hd__decap_3
XFILLER_52_414 VGND VGND VPWR VPWR sky130_fd_sc_hd__fill_1
XFILLER_64_274 VGND VGND VPWR VPWR sky130_fd_sc_hd__decap_3
XTAP_TAPCELL_ROW_69_1075 VGND VPWR sky130_fd_sc_hd__tapvpwrvgnd_1
XFILLER_52_436 VGND VGND VPWR VPWR sky130_fd_sc_hd__decap_3
XFILLER_52_458 VGND VGND VPWR VPWR sky130_fd_sc_hd__fill_2
XFILLER_64_296 VGND VGND VPWR VPWR sky130_fd_sc_hd__decap_3
XTAP_TAPCELL_ROW_82_1231 VGND VPWR sky130_fd_sc_hd__tapvpwrvgnd_1
XTAP_TAPCELL_ROW_35_667 VGND VPWR sky130_fd_sc_hd__tapvpwrvgnd_1
XANTENNA_12 _5094_/X VGND VGND VPWR VPWR sky130_fd_sc_hd__diode_2
XANTENNA_23 _7050_/Q VGND VGND VPWR VPWR sky130_fd_sc_hd__diode_2
XFILLER_20_333 VGND VGND VPWR VPWR sky130_fd_sc_hd__decap_3
XFILLER_60_480 VGND VGND VPWR VPWR sky130_fd_sc_hd__decap_3
X_4865_ _4865_/A0 _4864_/X _4879_/S VGND VGND VPWR VPWR _7270_/D sky130_fd_sc_hd__mux2_2
XANTENNA_34 _6984_/D VGND VGND VPWR VPWR sky130_fd_sc_hd__diode_2
X_6604_ _6604_/A VGND VGND VPWR VPWR _6604_/Y sky130_fd_sc_hd__inv_2
X_4796_ _4795_/A _4779_/X _4447_/B _4780_/Y _4814_/A VGND VGND VPWR VPWR _4796_/Y
+ sky130_fd_sc_hd__a311oi_2
X_3816_ _6792_/Q _3922_/A2 _3858_/B1 _6880_/Q _3815_/X VGND VGND VPWR VPWR _3816_/X
+ sky130_fd_sc_hd__a221o_2
XFILLER_20_377 VGND VGND VPWR VPWR sky130_fd_sc_hd__decap_3
XFILLER_21_27 VGND VGND VPWR VPWR sky130_fd_sc_hd__fill_2
X_6535_ _6535_/A VGND VGND VPWR VPWR _6535_/Y sky130_fd_sc_hd__inv_2
X_3747_ _3741_/X _3743_/X _3745_/X _3746_/X VGND VGND VPWR VPWR _3747_/X sky130_fd_sc_hd__a22o_2
XFILLER_106_427 VGND VGND VPWR VPWR sky130_fd_sc_hd__decap_3
XFILLER_108_9 VGND VGND VPWR VPWR sky130_fd_sc_hd__decap_3
X_6466_ _6634_/A VGND VGND VPWR VPWR _6466_/Y sky130_fd_sc_hd__inv_2
X_6397_ _6558_/A VGND VGND VPWR VPWR _6397_/Y sky130_fd_sc_hd__inv_2
X_5417_ _5417_/A0 _5125_/Y _5419_/S VGND VGND VPWR VPWR _7125_/D sky130_fd_sc_hd__mux2_2
XFILLER_87_311 VGND VGND VPWR VPWR sky130_fd_sc_hd__decap_3
X_5348_ _7157_/Q _5125_/Y _5350_/S VGND VGND VPWR VPWR _7157_/D sky130_fd_sc_hd__mux2_2
XTAP_TAPCELL_ROW_93_1371 VGND VPWR sky130_fd_sc_hd__tapvpwrvgnd_1
XTAP_TAPCELL_ROW_7_337 VGND VPWR sky130_fd_sc_hd__tapvpwrvgnd_1
XFILLER_101_154 VGND VGND VPWR VPWR sky130_fd_sc_hd__decap_3
XFILLER_47_208 VGND VGND VPWR VPWR sky130_fd_sc_hd__decap_3
XFILLER_75_528 VGND VGND VPWR VPWR sky130_fd_sc_hd__decap_3
XFILLER_87_355 VGND VGND VPWR VPWR sky130_fd_sc_hd__decap_3
XFILLER_87_388 VGND VGND VPWR VPWR sky130_fd_sc_hd__decap_3
X_7018_ _7362_/CLK _7018_/D _6298_/Y VGND VGND VPWR VPWR _7018_/Q sky130_fd_sc_hd__dfrtp_2
XFILLER_101_198 VGND VGND VPWR VPWR sky130_fd_sc_hd__decap_3
XFILLER_87_399 VGND VGND VPWR VPWR sky130_fd_sc_hd__decap_3
XFILLER_28_455 VGND VGND VPWR VPWR sky130_fd_sc_hd__decap_3
XFILLER_46_46 VGND VGND VPWR VPWR sky130_fd_sc_hd__decap_3
XFILLER_55_252 VGND VGND VPWR VPWR sky130_fd_sc_hd__decap_3
XFILLER_83_561 VGND VGND VPWR VPWR sky130_fd_sc_hd__decap_3
XFILLER_15_116 VGND VGND VPWR VPWR sky130_fd_sc_hd__decap_3
XFILLER_28_477 VGND VGND VPWR VPWR sky130_fd_sc_hd__decap_3
XFILLER_43_425 VGND VGND VPWR VPWR sky130_fd_sc_hd__decap_3
XFILLER_70_211 VGND VGND VPWR VPWR sky130_fd_sc_hd__decap_3
XFILLER_83_594 VGND VGND VPWR VPWR sky130_fd_sc_hd__decap_3
XFILLER_15_127 VGND VGND VPWR VPWR sky130_fd_sc_hd__fill_2
XFILLER_43_447 VGND VGND VPWR VPWR sky130_fd_sc_hd__fill_1
XFILLER_70_244 VGND VGND VPWR VPWR sky130_fd_sc_hd__decap_3
XFILLER_102_85 VGND VGND VPWR VPWR sky130_fd_sc_hd__decap_3
XFILLER_30_108 VGND VGND VPWR VPWR sky130_fd_sc_hd__decap_3
XFILLER_70_288 VGND VGND VPWR VPWR sky130_fd_sc_hd__decap_3
XFILLER_11_333 VGND VGND VPWR VPWR sky130_fd_sc_hd__decap_3
XFILLER_23_193 VGND VGND VPWR VPWR sky130_fd_sc_hd__fill_2
XFILLER_109_221 VGND VGND VPWR VPWR sky130_fd_sc_hd__decap_3
XFILLER_11_388 VGND VGND VPWR VPWR sky130_fd_sc_hd__fill_1
XFILLER_7_326 VGND VGND VPWR VPWR sky130_fd_sc_hd__fill_1
XFILLER_7_337 VGND VGND VPWR VPWR sky130_fd_sc_hd__decap_3
XFILLER_109_287 VGND VGND VPWR VPWR sky130_fd_sc_hd__decap_3
XFILLER_11_60 VGND VGND VPWR VPWR sky130_fd_sc_hd__decap_3
XFILLER_112_419 VGND VGND VPWR VPWR sky130_fd_sc_hd__fill_1
XFILLER_87_42 VGND VGND VPWR VPWR sky130_fd_sc_hd__fill_2
XFILLER_97_119 VGND VGND VPWR VPWR sky130_fd_sc_hd__decap_3
XFILLER_105_482 VGND VGND VPWR VPWR sky130_fd_sc_hd__decap_3
XFILLER_78_344 VGND VGND VPWR VPWR sky130_fd_sc_hd__decap_3
XFILLER_23_9 VGND VGND VPWR VPWR sky130_fd_sc_hd__decap_3
XFILLER_66_528 VGND VGND VPWR VPWR sky130_fd_sc_hd__decap_3
XFILLER_19_411 VGND VGND VPWR VPWR sky130_fd_sc_hd__decap_3
XFILLER_66_539 VGND VGND VPWR VPWR sky130_fd_sc_hd__decap_3
XFILLER_93_325 VGND VGND VPWR VPWR sky130_fd_sc_hd__decap_3
XFILLER_19_455 VGND VGND VPWR VPWR sky130_fd_sc_hd__fill_1
XFILLER_46_230 VGND VGND VPWR VPWR sky130_fd_sc_hd__decap_3
XFILLER_93_358 VGND VGND VPWR VPWR sky130_fd_sc_hd__decap_3
XFILLER_19_477 VGND VGND VPWR VPWR sky130_fd_sc_hd__decap_3
XFILLER_34_414 VGND VGND VPWR VPWR sky130_fd_sc_hd__decap_3
XFILLER_61_211 VGND VGND VPWR VPWR sky130_fd_sc_hd__decap_3
XFILLER_74_572 VGND VGND VPWR VPWR sky130_fd_sc_hd__decap_3
XTAP_TAPCELL_ROW_105_1507 VGND VPWR sky130_fd_sc_hd__tapvpwrvgnd_1
XFILLER_34_458 VGND VGND VPWR VPWR sky130_fd_sc_hd__fill_1
XFILLER_15_661 VGND VGND VPWR VPWR sky130_fd_sc_hd__decap_3
XFILLER_14_171 VGND VGND VPWR VPWR sky130_fd_sc_hd__decap_3
XFILLER_21_119 VGND VGND VPWR VPWR sky130_fd_sc_hd__decap_3
XFILLER_42_480 VGND VGND VPWR VPWR sky130_fd_sc_hd__fill_1
XTAP_TAPCELL_ROW_32_637 VGND VPWR sky130_fd_sc_hd__tapvpwrvgnd_1
XFILLER_14_193 VGND VGND VPWR VPWR sky130_fd_sc_hd__decap_3
X_4650_ _4440_/A _4650_/B VGND VGND VPWR VPWR _4810_/B sky130_fd_sc_hd__and2b_2
XTAP_TAPCELL_ROW_60_968 VGND VPWR sky130_fd_sc_hd__tapvpwrvgnd_1
X_3601_ _3427_/B _3600_/Y _3599_/A VGND VGND VPWR VPWR _4613_/B sky130_fd_sc_hd__a21oi_2
X_6320_ _6644_/A VGND VGND VPWR VPWR _6320_/Y sky130_fd_sc_hd__inv_2
X_4581_ _7290_/Q _4595_/B VGND VGND VPWR VPWR _7290_/D sky130_fd_sc_hd__and2_2
XTAP_TAPCELL_ROW_12_394 VGND VPWR sky130_fd_sc_hd__tapvpwrvgnd_1
Xhold805 _6961_/Q VGND VGND VPWR VPWR _6961_/D sky130_fd_sc_hd__dlygate4sd3_1
Xhold816 _6911_/Q VGND VGND VPWR VPWR _6911_/D sky130_fd_sc_hd__dlygate4sd3_1
Xhold827 _6851_/Q VGND VGND VPWR VPWR _6851_/D sky130_fd_sc_hd__dlygate4sd3_1
X_3532_ _3371_/A _3509_/Y _5642_/B _5659_/A _3956_/S VGND VGND VPWR VPWR _3621_/A
+ sky130_fd_sc_hd__a41o_2
XTAP_TAPCELL_ROW_116_1658 VGND VPWR sky130_fd_sc_hd__tapvpwrvgnd_1
XTAP_TAPCELL_ROW_116_1647 VGND VPWR sky130_fd_sc_hd__tapvpwrvgnd_1
Xhold838 _6736_/Q VGND VGND VPWR VPWR _6736_/D sky130_fd_sc_hd__dlygate4sd3_1
Xhold849 _7065_/Q VGND VGND VPWR VPWR _7065_/D sky130_fd_sc_hd__dlygate4sd3_1
Xmax_cap557 _5657_/B VGND VGND VPWR VPWR _4913_/A1 sky130_fd_sc_hd__clkbuf_2
X_3463_ _7057_/Q _4305_/B _4460_/A _3462_/X VGND VGND VPWR VPWR _3545_/A sky130_fd_sc_hd__o211ai_4
XFILLER_103_408 VGND VGND VPWR VPWR sky130_fd_sc_hd__decap_3
XFILLER_115_279 VGND VGND VPWR VPWR sky130_fd_sc_hd__fill_1
XFILLER_88_108 VGND VGND VPWR VPWR sky130_fd_sc_hd__decap_3
XFILLER_97_620 VGND VGND VPWR VPWR sky130_fd_sc_hd__decap_3
XFILLER_69_322 VGND VGND VPWR VPWR sky130_fd_sc_hd__decap_3
XFILLER_96_130 VGND VGND VPWR VPWR sky130_fd_sc_hd__decap_3
X_3394_ _3394_/A _3429_/B VGND VGND VPWR VPWR _3577_/B sky130_fd_sc_hd__or2_2
XFILLER_111_463 VGND VGND VPWR VPWR sky130_fd_sc_hd__decap_3
XFILLER_29_208 VGND VGND VPWR VPWR sky130_fd_sc_hd__decap_3
XFILLER_69_366 VGND VGND VPWR VPWR sky130_fd_sc_hd__decap_3
XFILLER_84_303 VGND VGND VPWR VPWR sky130_fd_sc_hd__decap_3
XFILLER_96_141 VGND VGND VPWR VPWR sky130_fd_sc_hd__decap_3
XFILLER_111_474 VGND VGND VPWR VPWR sky130_fd_sc_hd__decap_3
XFILLER_69_399 VGND VGND VPWR VPWR sky130_fd_sc_hd__decap_3
XFILLER_96_174 VGND VGND VPWR VPWR sky130_fd_sc_hd__decap_3
XFILLER_84_347 VGND VGND VPWR VPWR sky130_fd_sc_hd__decap_3
XFILLER_25_403 VGND VGND VPWR VPWR sky130_fd_sc_hd__decap_3
XFILLER_65_561 VGND VGND VPWR VPWR sky130_fd_sc_hd__decap_3
XFILLER_16_27 VGND VGND VPWR VPWR sky130_fd_sc_hd__fill_1
XFILLER_16_38 VGND VGND VPWR VPWR sky130_fd_sc_hd__fill_2
XFILLER_37_296 VGND VGND VPWR VPWR sky130_fd_sc_hd__decap_3
XFILLER_52_211 VGND VGND VPWR VPWR sky130_fd_sc_hd__decap_3
XFILLER_52_222 VGND VGND VPWR VPWR sky130_fd_sc_hd__decap_3
XFILLER_80_542 VGND VGND VPWR VPWR sky130_fd_sc_hd__decap_3
XFILLER_52_277 VGND VGND VPWR VPWR sky130_fd_sc_hd__decap_3
XFILLER_80_564 VGND VGND VPWR VPWR sky130_fd_sc_hd__decap_3
XFILLER_80_575 VGND VGND VPWR VPWR sky130_fd_sc_hd__decap_3
XFILLER_12_119 VGND VGND VPWR VPWR sky130_fd_sc_hd__decap_3
XFILLER_21_620 VGND VGND VPWR VPWR sky130_fd_sc_hd__fill_2
XFILLER_52_299 VGND VGND VPWR VPWR sky130_fd_sc_hd__decap_3
X_4917_ _4967_/A _4950_/A _4967_/B VGND VGND VPWR VPWR _4918_/B sky130_fd_sc_hd__and3_2
XFILLER_20_141 VGND VGND VPWR VPWR sky130_fd_sc_hd__decap_3
XFILLER_32_26 VGND VGND VPWR VPWR sky130_fd_sc_hd__fill_2
X_4848_ _4884_/A _4904_/B _4140_/X VGND VGND VPWR VPWR _4872_/B sky130_fd_sc_hd__o21ba_2
XFILLER_20_174 VGND VGND VPWR VPWR sky130_fd_sc_hd__decap_3
X_4779_ _4779_/A _4827_/B VGND VGND VPWR VPWR _4779_/X sky130_fd_sc_hd__or2_2
XFILLER_4_318 VGND VGND VPWR VPWR sky130_fd_sc_hd__decap_3
X_6518_ _6675_/A VGND VGND VPWR VPWR _6518_/Y sky130_fd_sc_hd__inv_2
XFILLER_106_246 VGND VGND VPWR VPWR sky130_fd_sc_hd__decap_3
X_6449_ _6611_/A VGND VGND VPWR VPWR _6449_/Y sky130_fd_sc_hd__inv_2
XFILLER_0_502 VGND VGND VPWR VPWR sky130_fd_sc_hd__fill_2
XFILLER_0_513 VGND VGND VPWR VPWR sky130_fd_sc_hd__fill_2
XFILLER_106_268 VGND VGND VPWR VPWR sky130_fd_sc_hd__fill_2
XFILLER_106_279 VGND VGND VPWR VPWR sky130_fd_sc_hd__decap_3
XFILLER_102_430 VGND VGND VPWR VPWR sky130_fd_sc_hd__decap_3
XFILLER_102_496 VGND VGND VPWR VPWR sky130_fd_sc_hd__decap_3
XFILLER_57_78 VGND VGND VPWR VPWR sky130_fd_sc_hd__decap_3
XFILLER_87_185 VGND VGND VPWR VPWR sky130_fd_sc_hd__decap_3
XFILLER_113_51 VGND VGND VPWR VPWR sky130_fd_sc_hd__decap_3
XFILLER_28_274 VGND VGND VPWR VPWR sky130_fd_sc_hd__decap_3
XFILLER_73_11 VGND VGND VPWR VPWR sky130_fd_sc_hd__fill_1
XFILLER_73_22 VGND VGND VPWR VPWR sky130_fd_sc_hd__decap_3
XFILLER_90_339 VGND VGND VPWR VPWR sky130_fd_sc_hd__decap_3
XFILLER_113_84 VGND VGND VPWR VPWR sky130_fd_sc_hd__decap_3
XFILLER_16_436 VGND VGND VPWR VPWR sky130_fd_sc_hd__decap_3
XFILLER_71_531 VGND VGND VPWR VPWR sky130_fd_sc_hd__decap_3
XFILLER_73_55 VGND VGND VPWR VPWR sky130_fd_sc_hd__fill_1
XFILLER_83_391 VGND VGND VPWR VPWR sky130_fd_sc_hd__fill_1
XFILLER_43_266 VGND VGND VPWR VPWR sky130_fd_sc_hd__decap_3
XFILLER_71_564 VGND VGND VPWR VPWR sky130_fd_sc_hd__decap_3
XFILLER_73_66 VGND VGND VPWR VPWR sky130_fd_sc_hd__decap_3
XFILLER_24_480 VGND VGND VPWR VPWR sky130_fd_sc_hd__decap_3
XFILLER_43_299 VGND VGND VPWR VPWR sky130_fd_sc_hd__decap_3
XFILLER_73_99 VGND VGND VPWR VPWR sky130_fd_sc_hd__decap_3
XFILLER_24_491 VGND VGND VPWR VPWR sky130_fd_sc_hd__fill_1
XTAP_TAPCELL_ROW_100_1448 VGND VPWR sky130_fd_sc_hd__tapvpwrvgnd_1
XFILLER_11_152 VGND VGND VPWR VPWR sky130_fd_sc_hd__decap_3
XFILLER_7_134 VGND VGND VPWR VPWR sky130_fd_sc_hd__decap_3
XFILLER_7_178 VGND VGND VPWR VPWR sky130_fd_sc_hd__decap_3
XFILLER_98_85 VGND VGND VPWR VPWR sky130_fd_sc_hd__decap_3
XFILLER_98_63 VGND VGND VPWR VPWR sky130_fd_sc_hd__decap_3
XFILLER_112_227 VGND VGND VPWR VPWR sky130_fd_sc_hd__decap_3
XFILLER_3_384 VGND VGND VPWR VPWR sky130_fd_sc_hd__fill_2
XFILLER_79_620 VGND VGND VPWR VPWR sky130_fd_sc_hd__decap_3
XFILLER_105_290 VGND VGND VPWR VPWR sky130_fd_sc_hd__decap_3
XFILLER_21_6 VGND VGND VPWR VPWR sky130_fd_sc_hd__decap_3
XFILLER_78_141 VGND VGND VPWR VPWR sky130_fd_sc_hd__decap_3
XFILLER_79_653 VGND VGND VPWR VPWR sky130_fd_sc_hd__decap_3
XTAP_TAPCELL_ROW_111_1588 VGND VPWR sky130_fd_sc_hd__tapvpwrvgnd_1
XFILLER_78_185 VGND VGND VPWR VPWR sky130_fd_sc_hd__decap_3
XFILLER_93_100 VGND VGND VPWR VPWR sky130_fd_sc_hd__decap_3
XFILLER_93_122 VGND VGND VPWR VPWR sky130_fd_sc_hd__decap_3
XFILLER_94_645 VGND VGND VPWR VPWR sky130_fd_sc_hd__decap_3
XFILLER_66_347 VGND VGND VPWR VPWR sky130_fd_sc_hd__fill_1
XFILLER_93_155 VGND VGND VPWR VPWR sky130_fd_sc_hd__decap_3
XFILLER_19_252 VGND VGND VPWR VPWR sky130_fd_sc_hd__decap_3
XFILLER_34_200 VGND VGND VPWR VPWR sky130_fd_sc_hd__decap_3
XFILLER_81_306 VGND VGND VPWR VPWR sky130_fd_sc_hd__decap_3
XFILLER_93_188 VGND VGND VPWR VPWR sky130_fd_sc_hd__decap_3
XFILLER_19_296 VGND VGND VPWR VPWR sky130_fd_sc_hd__decap_3
XFILLER_62_520 VGND VGND VPWR VPWR sky130_fd_sc_hd__decap_3
XTAP_TAPCELL_ROW_66_1045 VGND VPWR sky130_fd_sc_hd__tapvpwrvgnd_1
XTAP_TAPCELL_ROW_17_453 VGND VPWR sky130_fd_sc_hd__tapvpwrvgnd_1
XFILLER_34_277 VGND VGND VPWR VPWR sky130_fd_sc_hd__decap_3
XTAP_TAPCELL_ROW_45_795 VGND VPWR sky130_fd_sc_hd__tapvpwrvgnd_1
XPHY_EDGE_ROW_22_Left_139 VGND VGND VPWR VPWR sky130_fd_sc_hd__decap_3
X_4702_ _6991_/Q _5026_/A VGND VGND VPWR VPWR _5001_/A sky130_fd_sc_hd__and2_2
XFILLER_30_472 VGND VGND VPWR VPWR sky130_fd_sc_hd__decap_3
XFILLER_30_483 VGND VGND VPWR VPWR sky130_fd_sc_hd__decap_3
X_5682_ _7347_/Q hold952/X _5708_/S VGND VGND VPWR VPWR _5682_/X sky130_fd_sc_hd__mux2_2
XFILLER_8_83 VGND VGND VPWR VPWR sky130_fd_sc_hd__fill_1
XFILLER_8_94 VGND VGND VPWR VPWR sky130_fd_sc_hd__decap_3
X_4633_ _4633_/A _4903_/A _4845_/A _4890_/B VGND VGND VPWR VPWR _4633_/X sky130_fd_sc_hd__or4_2
XFILLER_116_522 VGND VGND VPWR VPWR sky130_fd_sc_hd__decap_3
X_7352_ clkload8/A _7352_/D _6632_/Y VGND VGND VPWR VPWR _7352_/Q sky130_fd_sc_hd__dfrtp_2
Xhold602 _6750_/Q VGND VGND VPWR VPWR _6750_/D sky130_fd_sc_hd__dlygate4sd3_1
XFILLER_116_533 VGND VGND VPWR VPWR sky130_fd_sc_hd__fill_1
X_7283_ clkload2/A _7283_/D _6563_/Y VGND VGND VPWR VPWR _7283_/Q sky130_fd_sc_hd__dfrtp_2
Xhold613 _6978_/Q VGND VGND VPWR VPWR _6978_/D sky130_fd_sc_hd__dlygate4sd3_1
Xhold624 _6901_/Q VGND VGND VPWR VPWR _6901_/D sky130_fd_sc_hd__dlygate4sd3_1
Xhold635 _6789_/Q VGND VGND VPWR VPWR _6789_/D sky130_fd_sc_hd__dlygate4sd3_1
X_6303_ _6611_/A VGND VGND VPWR VPWR _6303_/Y sky130_fd_sc_hd__inv_2
X_3515_ _3509_/Y _3510_/X _4419_/B1 VGND VGND VPWR VPWR _4938_/A sky130_fd_sc_hd__a21o_2
XTAP_TAPCELL_ROW_77_1174 VGND VPWR sky130_fd_sc_hd__tapvpwrvgnd_1
XFILLER_103_205 VGND VGND VPWR VPWR sky130_fd_sc_hd__decap_3
XFILLER_116_577 VGND VGND VPWR VPWR sky130_fd_sc_hd__fill_1
XFILLER_89_417 VGND VGND VPWR VPWR sky130_fd_sc_hd__decap_3
Xhold646 _6768_/Q VGND VGND VPWR VPWR _6768_/D sky130_fd_sc_hd__dlygate4sd3_1
Xhold657 _6925_/Q VGND VGND VPWR VPWR _6925_/D sky130_fd_sc_hd__dlygate4sd3_1
Xhold668 _6820_/Q VGND VGND VPWR VPWR _6820_/D sky130_fd_sc_hd__dlygate4sd3_1
Xhold679 _6807_/Q VGND VGND VPWR VPWR _6807_/D sky130_fd_sc_hd__dlygate4sd3_1
X_4495_ _4495_/A0 _7300_/Q _4501_/S VGND VGND VPWR VPWR _7332_/D sky130_fd_sc_hd__mux2_2
XPHY_EDGE_ROW_31_Left_148 VGND VGND VPWR VPWR sky130_fd_sc_hd__decap_3
XFILLER_103_249 VGND VGND VPWR VPWR sky130_fd_sc_hd__decap_3
XTAP_TAPCELL_ROW_90_1330 VGND VPWR sky130_fd_sc_hd__tapvpwrvgnd_1
XFILLER_69_152 VGND VGND VPWR VPWR sky130_fd_sc_hd__decap_3
XFILLER_85_601 VGND VGND VPWR VPWR sky130_fd_sc_hd__decap_3
XFILLER_97_461 VGND VGND VPWR VPWR sky130_fd_sc_hd__decap_3
X_3377_ _3394_/A _3429_/A _5641_/A _5161_/A VGND VGND VPWR VPWR _3377_/X sky130_fd_sc_hd__and4bb_4
XFILLER_57_314 VGND VGND VPWR VPWR sky130_fd_sc_hd__decap_3
XFILLER_84_100 VGND VGND VPWR VPWR sky130_fd_sc_hd__decap_3
XFILLER_85_634 VGND VGND VPWR VPWR sky130_fd_sc_hd__decap_3
XFILLER_97_494 VGND VGND VPWR VPWR sky130_fd_sc_hd__decap_3
X_5116_ _5110_/Y _5111_/X _5115_/X VGND VGND VPWR VPWR _5658_/D sky130_fd_sc_hd__o21ai_4
XFILLER_57_358 VGND VGND VPWR VPWR sky130_fd_sc_hd__decap_3
XFILLER_69_196 VGND VGND VPWR VPWR sky130_fd_sc_hd__decap_3
XFILLER_84_133 VGND VGND VPWR VPWR sky130_fd_sc_hd__decap_3
X_5047_ _5114_/B _4617_/B _4617_/C _5100_/A VGND VGND VPWR VPWR _5047_/Y sky130_fd_sc_hd__o31ai_2
XFILLER_25_211 VGND VGND VPWR VPWR sky130_fd_sc_hd__decap_3
XFILLER_25_233 VGND VGND VPWR VPWR sky130_fd_sc_hd__decap_3
XFILLER_25_266 VGND VGND VPWR VPWR sky130_fd_sc_hd__decap_3
XFILLER_43_14 VGND VGND VPWR VPWR sky130_fd_sc_hd__decap_3
XFILLER_80_350 VGND VGND VPWR VPWR sky130_fd_sc_hd__decap_3
X_6998_ _7368_/CLK _6998_/D _6278_/Y VGND VGND VPWR VPWR _6998_/Q sky130_fd_sc_hd__dfrtp_2
XPHY_EDGE_ROW_40_Left_157 VGND VGND VPWR VPWR sky130_fd_sc_hd__decap_3
XFILLER_13_428 VGND VGND VPWR VPWR sky130_fd_sc_hd__decap_3
XFILLER_25_299 VGND VGND VPWR VPWR sky130_fd_sc_hd__decap_3
XFILLER_40_203 VGND VGND VPWR VPWR sky130_fd_sc_hd__decap_3
XFILLER_80_394 VGND VGND VPWR VPWR sky130_fd_sc_hd__decap_3
XFILLER_40_247 VGND VGND VPWR VPWR sky130_fd_sc_hd__decap_3
XFILLER_21_494 VGND VGND VPWR VPWR sky130_fd_sc_hd__decap_3
XFILLER_107_500 VGND VGND VPWR VPWR sky130_fd_sc_hd__decap_3
XFILLER_107_522 VGND VGND VPWR VPWR sky130_fd_sc_hd__decap_3
XFILLER_104_3 VGND VGND VPWR VPWR sky130_fd_sc_hd__decap_3
XFILLER_107_555 VGND VGND VPWR VPWR sky130_fd_sc_hd__decap_3
XFILLER_68_11 VGND VGND VPWR VPWR sky130_fd_sc_hd__decap_3
XFILLER_0_321 VGND VGND VPWR VPWR sky130_fd_sc_hd__decap_3
XFILLER_68_44 VGND VGND VPWR VPWR sky130_fd_sc_hd__decap_3
XFILLER_0_365 VGND VGND VPWR VPWR sky130_fd_sc_hd__decap_3
XFILLER_102_271 VGND VGND VPWR VPWR sky130_fd_sc_hd__decap_3
XFILLER_48_303 VGND VGND VPWR VPWR sky130_fd_sc_hd__decap_3
XFILLER_68_88 VGND VGND VPWR VPWR sky130_fd_sc_hd__decap_3
XFILLER_75_111 VGND VGND VPWR VPWR sky130_fd_sc_hd__fill_1
XFILLER_76_623 VGND VGND VPWR VPWR sky130_fd_sc_hd__decap_3
XFILLER_76_634 VGND VGND VPWR VPWR sky130_fd_sc_hd__decap_3
XFILLER_88_483 VGND VGND VPWR VPWR sky130_fd_sc_hd__decap_3
XFILLER_48_336 VGND VGND VPWR VPWR sky130_fd_sc_hd__decap_3
XFILLER_76_645 VGND VGND VPWR VPWR sky130_fd_sc_hd__decap_3
XFILLER_84_21 VGND VGND VPWR VPWR sky130_fd_sc_hd__decap_3
XFILLER_63_317 VGND VGND VPWR VPWR sky130_fd_sc_hd__decap_3
XFILLER_90_103 VGND VGND VPWR VPWR sky130_fd_sc_hd__decap_3
XFILLER_91_615 VGND VGND VPWR VPWR sky130_fd_sc_hd__fill_1
XFILLER_16_200 VGND VGND VPWR VPWR sky130_fd_sc_hd__decap_3
XFILLER_16_233 VGND VGND VPWR VPWR sky130_fd_sc_hd__decap_3
XFILLER_44_520 VGND VGND VPWR VPWR sky130_fd_sc_hd__fill_2
XFILLER_44_531 VGND VGND VPWR VPWR sky130_fd_sc_hd__fill_1
XFILLER_44_542 VGND VGND VPWR VPWR sky130_fd_sc_hd__decap_3
XFILLER_56_380 VGND VGND VPWR VPWR sky130_fd_sc_hd__fill_2
XFILLER_75_199 VGND VGND VPWR VPWR sky130_fd_sc_hd__decap_3
XFILLER_84_76 VGND VGND VPWR VPWR sky130_fd_sc_hd__decap_3
Xplace328 _5708_/S VGND VGND VPWR VPWR _5706_/S sky130_fd_sc_hd__buf_2
Xplace317 _5245_/S VGND VGND VPWR VPWR _5274_/S sky130_fd_sc_hd__buf_2
Xplace306 _4811_/C VGND VGND VPWR VPWR _5103_/A1 sky130_fd_sc_hd__buf_2
XFILLER_17_70 VGND VGND VPWR VPWR sky130_fd_sc_hd__decap_3
XFILLER_71_361 VGND VGND VPWR VPWR sky130_fd_sc_hd__decap_3
Xplace339 _3377_/X VGND VGND VPWR VPWR _4340_/A2 sky130_fd_sc_hd__buf_2
XFILLER_16_277 VGND VGND VPWR VPWR sky130_fd_sc_hd__decap_3
XFILLER_31_203 VGND VGND VPWR VPWR sky130_fd_sc_hd__decap_3
XFILLER_44_597 VGND VGND VPWR VPWR sky130_fd_sc_hd__fill_1
XFILLER_31_236 VGND VGND VPWR VPWR sky130_fd_sc_hd__decap_3
XTAP_TAPCELL_ROW_42_754 VGND VPWR sky130_fd_sc_hd__tapvpwrvgnd_1
XTAP_TAPCELL_ROW_14_423 VGND VPWR sky130_fd_sc_hd__tapvpwrvgnd_1
XFILLER_12_450 VGND VGND VPWR VPWR sky130_fd_sc_hd__fill_1
XFILLER_8_421 VGND VGND VPWR VPWR sky130_fd_sc_hd__fill_2
XTAP_TAPCELL_ROW_113_1606 VGND VPWR sky130_fd_sc_hd__tapvpwrvgnd_1
XFILLER_113_503 VGND VGND VPWR VPWR sky130_fd_sc_hd__fill_1
XFILLER_113_514 VGND VGND VPWR VPWR sky130_fd_sc_hd__decap_3
X_3300_ _5129_/B VGND VGND VPWR VPWR _4467_/A sky130_fd_sc_hd__inv_2
X_4280_ _7222_/Q _3377_/X _4348_/A2 _7158_/Q _4279_/X VGND VGND VPWR VPWR _4280_/X
+ sky130_fd_sc_hd__a221o_2
XFILLER_98_247 VGND VGND VPWR VPWR sky130_fd_sc_hd__decap_3
XFILLER_3_192 VGND VGND VPWR VPWR sky130_fd_sc_hd__decap_3
XFILLER_79_461 VGND VGND VPWR VPWR sky130_fd_sc_hd__decap_3
XFILLER_100_219 VGND VGND VPWR VPWR sky130_fd_sc_hd__decap_3
XFILLER_67_612 VGND VGND VPWR VPWR sky130_fd_sc_hd__decap_3
XFILLER_67_623 VGND VGND VPWR VPWR sky130_fd_sc_hd__decap_3
XFILLER_67_634 VGND VGND VPWR VPWR sky130_fd_sc_hd__decap_3
XFILLER_66_122 VGND VGND VPWR VPWR sky130_fd_sc_hd__decap_3
XFILLER_66_144 VGND VGND VPWR VPWR sky130_fd_sc_hd__decap_3
XFILLER_94_442 VGND VGND VPWR VPWR sky130_fd_sc_hd__decap_3
XFILLER_39_369 VGND VGND VPWR VPWR sky130_fd_sc_hd__decap_3
XFILLER_54_317 VGND VGND VPWR VPWR sky130_fd_sc_hd__decap_3
XFILLER_66_177 VGND VGND VPWR VPWR sky130_fd_sc_hd__fill_1
XFILLER_67_689 VGND VGND VPWR VPWR sky130_fd_sc_hd__decap_3
XFILLER_82_615 VGND VGND VPWR VPWR sky130_fd_sc_hd__decap_3
XFILLER_35_531 VGND VGND VPWR VPWR sky130_fd_sc_hd__decap_3
XFILLER_47_380 VGND VGND VPWR VPWR sky130_fd_sc_hd__decap_3
XFILLER_66_188 VGND VGND VPWR VPWR sky130_fd_sc_hd__decap_3
X_6921_ _6929_/CLK _6921_/D VGND VGND VPWR VPWR _6921_/Q sky130_fd_sc_hd__dfxtp_2
XFILLER_62_350 VGND VGND VPWR VPWR sky130_fd_sc_hd__decap_3
XFILLER_81_169 VGND VGND VPWR VPWR sky130_fd_sc_hd__decap_3
X_6852_ _6968_/CLK _6852_/D VGND VGND VPWR VPWR _6852_/Q sky130_fd_sc_hd__dfxtp_2
XFILLER_22_203 VGND VGND VPWR VPWR sky130_fd_sc_hd__decap_3
XFILLER_50_523 VGND VGND VPWR VPWR sky130_fd_sc_hd__fill_2
XFILLER_90_681 VGND VGND VPWR VPWR sky130_fd_sc_hd__decap_3
Xfanout18 _6540_/A VGND VGND VPWR VPWR _6539_/A sky130_fd_sc_hd__buf_2
Xfanout29 _6536_/A VGND VGND VPWR VPWR _6600_/A sky130_fd_sc_hd__clkdlybuf4s25_1
XFILLER_22_236 VGND VGND VPWR VPWR sky130_fd_sc_hd__decap_3
X_6783_ _6929_/CLK _6783_/D VGND VGND VPWR VPWR _6783_/Q sky130_fd_sc_hd__dfxtp_2
XFILLER_13_17 VGND VGND VPWR VPWR sky130_fd_sc_hd__decap_3
XFILLER_50_589 VGND VGND VPWR VPWR sky130_fd_sc_hd__decap_3
XFILLER_30_280 VGND VGND VPWR VPWR sky130_fd_sc_hd__decap_3
X_5665_ _5665_/A _5665_/B _5665_/C _5665_/D VGND VGND VPWR VPWR _5666_/B sky130_fd_sc_hd__and4_2
XTAP_TAPCELL_ROW_79_1203 VGND VPWR sky130_fd_sc_hd__tapvpwrvgnd_1
X_7404_ _7404_/CLK _7404_/D _6684_/Y VGND VGND VPWR VPWR _7404_/Q sky130_fd_sc_hd__dfrtp_2
X_4616_ _3547_/A _3547_/B _4614_/X _4615_/Y VGND VGND VPWR VPWR _4617_/C sky130_fd_sc_hd__a31o_2
XFILLER_116_330 VGND VGND VPWR VPWR sky130_fd_sc_hd__decap_3
X_7335_ _7371_/CLK _7335_/D _6615_/Y VGND VGND VPWR VPWR _7335_/Q sky130_fd_sc_hd__dfrtp_2
XPHY_EDGE_ROW_111_Right_111 VGND VGND VPWR VPWR sky130_fd_sc_hd__decap_3
XFILLER_104_514 VGND VGND VPWR VPWR sky130_fd_sc_hd__decap_3
XFILLER_104_547 VGND VGND VPWR VPWR sky130_fd_sc_hd__decap_3
XFILLER_116_385 VGND VGND VPWR VPWR sky130_fd_sc_hd__decap_3
XFILLER_116_396 VGND VGND VPWR VPWR sky130_fd_sc_hd__decap_3
X_7266_ _7362_/CLK _7266_/D _6546_/Y VGND VGND VPWR VPWR _7266_/Q sky130_fd_sc_hd__dfrtp_2
X_4478_ _4478_/A0 _4544_/A _4491_/S VGND VGND VPWR VPWR _7340_/D sky130_fd_sc_hd__mux2_2
XFILLER_89_269 VGND VGND VPWR VPWR sky130_fd_sc_hd__fill_2
X_7197_ _7360_/CLK _7197_/D _6477_/Y VGND VGND VPWR VPWR _7197_/Q sky130_fd_sc_hd__dfrtp_2
X_3429_ _3429_/A _3429_/B VGND VGND VPWR VPWR _3590_/A sky130_fd_sc_hd__or2_2
XFILLER_57_100 VGND VGND VPWR VPWR sky130_fd_sc_hd__decap_3
XFILLER_85_420 VGND VGND VPWR VPWR sky130_fd_sc_hd__decap_3
XFILLER_38_69 VGND VGND VPWR VPWR sky130_fd_sc_hd__fill_1
XFILLER_57_122 VGND VGND VPWR VPWR sky130_fd_sc_hd__decap_3
Xhold1110 _7335_/Q VGND VGND VPWR VPWR _4488_/A0 sky130_fd_sc_hd__dlygate4sd3_1
Xhold1121 _7145_/Q VGND VGND VPWR VPWR _5375_/A0 sky130_fd_sc_hd__dlygate4sd3_1
Xhold1132 _7312_/Q VGND VGND VPWR VPWR _4534_/A0 sky130_fd_sc_hd__dlygate4sd3_1
XFILLER_57_177 VGND VGND VPWR VPWR sky130_fd_sc_hd__decap_3
XFILLER_73_615 VGND VGND VPWR VPWR sky130_fd_sc_hd__fill_1
XFILLER_85_486 VGND VGND VPWR VPWR sky130_fd_sc_hd__decap_3
Xhold1143 _7395_/Q VGND VGND VPWR VPWR _3763_/A1 sky130_fd_sc_hd__dlygate4sd3_1
Xhold1154 _7234_/Q VGND VGND VPWR VPWR _5188_/A sky130_fd_sc_hd__dlygate4sd3_1
Xhold1165 _7129_/Q VGND VGND VPWR VPWR _5409_/A0 sky130_fd_sc_hd__dlygate4sd3_1
Xhold1176 _7326_/Q VGND VGND VPWR VPWR _4507_/A0 sky130_fd_sc_hd__dlygate4sd3_1
XFILLER_45_328 VGND VGND VPWR VPWR sky130_fd_sc_hd__decap_3
XFILLER_72_125 VGND VGND VPWR VPWR sky130_fd_sc_hd__decap_3
Xhold1187 _7229_/Q VGND VGND VPWR VPWR _5198_/A sky130_fd_sc_hd__dlygate4sd3_1
Xhold1198 _7182_/Q VGND VGND VPWR VPWR _5296_/A0 sky130_fd_sc_hd__dlygate4sd3_1
XFILLER_26_553 VGND VGND VPWR VPWR sky130_fd_sc_hd__fill_2
XFILLER_54_35 VGND VGND VPWR VPWR sky130_fd_sc_hd__decap_3
XFILLER_60_309 VGND VGND VPWR VPWR sky130_fd_sc_hd__decap_3
XFILLER_13_214 VGND VGND VPWR VPWR sky130_fd_sc_hd__decap_3
XFILLER_13_225 VGND VGND VPWR VPWR sky130_fd_sc_hd__decap_3
XFILLER_41_501 VGND VGND VPWR VPWR sky130_fd_sc_hd__decap_3
XFILLER_110_85 VGND VGND VPWR VPWR sky130_fd_sc_hd__fill_1
XFILLER_41_578 VGND VGND VPWR VPWR sky130_fd_sc_hd__fill_2
XFILLER_70_78 VGND VGND VPWR VPWR sky130_fd_sc_hd__decap_3
XFILLER_5_435 VGND VGND VPWR VPWR sky130_fd_sc_hd__decap_3
XFILLER_107_352 VGND VGND VPWR VPWR sky130_fd_sc_hd__decap_3
XFILLER_107_385 VGND VGND VPWR VPWR sky130_fd_sc_hd__decap_3
XFILLER_110_506 VGND VGND VPWR VPWR sky130_fd_sc_hd__fill_1
XFILLER_79_98 VGND VGND VPWR VPWR sky130_fd_sc_hd__decap_3
XFILLER_95_228 VGND VGND VPWR VPWR sky130_fd_sc_hd__decap_3
XFILLER_103_591 VGND VGND VPWR VPWR sky130_fd_sc_hd__decap_3
XFILLER_48_122 VGND VGND VPWR VPWR sky130_fd_sc_hd__decap_3
XFILLER_48_155 VGND VGND VPWR VPWR sky130_fd_sc_hd__decap_3
XFILLER_76_475 VGND VGND VPWR VPWR sky130_fd_sc_hd__fill_1
XFILLER_76_486 VGND VGND VPWR VPWR sky130_fd_sc_hd__decap_3
XTAP_TAPCELL_ROW_47_813 VGND VPWR sky130_fd_sc_hd__tapvpwrvgnd_1
XFILLER_17_531 VGND VGND VPWR VPWR sky130_fd_sc_hd__fill_2
XFILLER_29_380 VGND VGND VPWR VPWR sky130_fd_sc_hd__decap_3
XFILLER_63_125 VGND VGND VPWR VPWR sky130_fd_sc_hd__fill_1
XFILLER_63_136 VGND VGND VPWR VPWR sky130_fd_sc_hd__decap_3
XFILLER_64_648 VGND VGND VPWR VPWR sky130_fd_sc_hd__decap_3
XFILLER_64_659 VGND VGND VPWR VPWR sky130_fd_sc_hd__decap_3
XFILLER_32_512 VGND VGND VPWR VPWR sky130_fd_sc_hd__decap_3
XFILLER_44_383 VGND VGND VPWR VPWR sky130_fd_sc_hd__decap_3
XTAP_TAPCELL_ROW_63_1004 VGND VPWR sky130_fd_sc_hd__tapvpwrvgnd_1
XTAP_TAPCELL_ROW_27_570 VGND VPWR sky130_fd_sc_hd__tapvpwrvgnd_1
XFILLER_44_394 VGND VGND VPWR VPWR sky130_fd_sc_hd__decap_3
XTAP_TAPCELL_ROW_27_581 VGND VPWR sky130_fd_sc_hd__tapvpwrvgnd_1
XFILLER_32_589 VGND VGND VPWR VPWR sky130_fd_sc_hd__fill_1
X_3780_ _6967_/Q _3661_/X _3651_/Y _6955_/Q VGND VGND VPWR VPWR _3780_/X sky130_fd_sc_hd__a22o_2
XFILLER_12_280 VGND VGND VPWR VPWR sky130_fd_sc_hd__decap_3
XFILLER_8_262 VGND VGND VPWR VPWR sky130_fd_sc_hd__decap_3
XFILLER_67_3 VGND VGND VPWR VPWR sky130_fd_sc_hd__fill_2
XFILLER_8_295 VGND VGND VPWR VPWR sky130_fd_sc_hd__decap_3
X_4401_ _7274_/Q _4422_/A2 _4430_/A2 _7242_/Q _4400_/X VGND VGND VPWR VPWR _4401_/X
+ sky130_fd_sc_hd__a221o_2
Xoutput526 _6988_/Q VGND VGND VPWR VPWR pc_out[11] sky130_fd_sc_hd__clkdlybuf4s25_1
Xoutput515 _3509_/B VGND VGND VPWR VPWR instruction_out[2] sky130_fd_sc_hd__clkdlybuf4s25_1
Xoutput504 _5641_/Y VGND VGND VPWR VPWR instruction_out[17] sky130_fd_sc_hd__clkdlybuf4s25_1
X_5381_ _7142_/Q _4864_/X _5383_/S VGND VGND VPWR VPWR _7142_/D sky130_fd_sc_hd__mux2_2
XFILLER_113_311 VGND VGND VPWR VPWR sky130_fd_sc_hd__decap_3
XFILLER_5_51 VGND VGND VPWR VPWR sky130_fd_sc_hd__decap_3
X_7120_ clkload7/A _7120_/D _6400_/Y VGND VGND VPWR VPWR _7120_/Q sky130_fd_sc_hd__dfrtp_2
Xoutput548 _7008_/Q VGND VGND VPWR VPWR pc_out[31] sky130_fd_sc_hd__clkdlybuf4s25_1
Xoutput537 _6998_/Q VGND VGND VPWR VPWR pc_out[21] sky130_fd_sc_hd__clkdlybuf4s25_1
X_4332_ _7191_/Q _3996_/S _4332_/B1 _7383_/Q _4331_/X VGND VGND VPWR VPWR _4332_/X
+ sky130_fd_sc_hd__a221o_2
XTAP_TAPCELL_ROW_74_1144 VGND VPWR sky130_fd_sc_hd__tapvpwrvgnd_1
XFILLER_99_523 VGND VGND VPWR VPWR sky130_fd_sc_hd__decap_3
XFILLER_113_355 VGND VGND VPWR VPWR sky130_fd_sc_hd__decap_3
XFILLER_5_84 VGND VGND VPWR VPWR sky130_fd_sc_hd__decap_3
X_7051_ _7406_/CLK _7051_/D _6331_/Y VGND VGND VPWR VPWR _7051_/Q sky130_fd_sc_hd__dfrtp_2
X_4263_ _7134_/Q _3378_/Y _4261_/X _4262_/X VGND VGND VPWR VPWR _4264_/B sky130_fd_sc_hd__a211o_2
XFILLER_99_578 VGND VGND VPWR VPWR sky130_fd_sc_hd__decap_3
XFILLER_99_567 VGND VGND VPWR VPWR sky130_fd_sc_hd__fill_1
XFILLER_101_517 VGND VGND VPWR VPWR sky130_fd_sc_hd__decap_3
XFILLER_113_388 VGND VGND VPWR VPWR sky130_fd_sc_hd__decap_3
XFILLER_86_239 VGND VGND VPWR VPWR sky130_fd_sc_hd__decap_3
XPHY_EDGE_ROW_105_Left_222 VGND VGND VPWR VPWR sky130_fd_sc_hd__decap_3
XFILLER_39_111 VGND VGND VPWR VPWR sky130_fd_sc_hd__fill_1
XFILLER_39_122 VGND VGND VPWR VPWR sky130_fd_sc_hd__decap_3
XFILLER_67_442 VGND VGND VPWR VPWR sky130_fd_sc_hd__decap_3
X_4194_ _7231_/Q _4414_/A2 _4418_/A2 _7017_/Q _4193_/X VGND VGND VPWR VPWR _4194_/X
+ sky130_fd_sc_hd__a221o_2
XFILLER_67_475 VGND VGND VPWR VPWR sky130_fd_sc_hd__decap_3
XFILLER_94_250 VGND VGND VPWR VPWR sky130_fd_sc_hd__fill_2
XFILLER_27_328 VGND VGND VPWR VPWR sky130_fd_sc_hd__decap_3
XFILLER_39_188 VGND VGND VPWR VPWR sky130_fd_sc_hd__decap_3
XFILLER_55_637 VGND VGND VPWR VPWR sky130_fd_sc_hd__decap_3
XFILLER_82_412 VGND VGND VPWR VPWR sky130_fd_sc_hd__fill_2
XFILLER_82_445 VGND VGND VPWR VPWR sky130_fd_sc_hd__decap_3
XFILLER_70_607 VGND VGND VPWR VPWR sky130_fd_sc_hd__decap_3
X_6904_ _7198_/CLK _6904_/D VGND VGND VPWR VPWR _6904_/Q sky130_fd_sc_hd__dfxtp_2
XTAP_TAPCELL_ROW_85_1273 VGND VPWR sky130_fd_sc_hd__tapvpwrvgnd_1
XFILLER_24_38 VGND VGND VPWR VPWR sky130_fd_sc_hd__decap_3
XFILLER_50_342 VGND VGND VPWR VPWR sky130_fd_sc_hd__decap_3
XFILLER_62_191 VGND VGND VPWR VPWR sky130_fd_sc_hd__decap_3
X_6835_ _7351_/CLK _6835_/D VGND VGND VPWR VPWR _6835_/Q sky130_fd_sc_hd__dfxtp_2
XFILLER_50_375 VGND VGND VPWR VPWR sky130_fd_sc_hd__decap_3
X_6766_ _6965_/CLK _6766_/D VGND VGND VPWR VPWR _6766_/Q sky130_fd_sc_hd__dfxtp_2
XPHY_EDGE_ROW_114_Left_231 VGND VGND VPWR VPWR sky130_fd_sc_hd__decap_3
X_5717_ _7364_/Q hold919/X _5729_/S VGND VGND VPWR VPWR _6708_/D sky130_fd_sc_hd__mux2_2
XFILLER_109_617 VGND VGND VPWR VPWR sky130_fd_sc_hd__decap_3
XFILLER_40_15 VGND VGND VPWR VPWR sky130_fd_sc_hd__decap_3
X_6697_ _7383_/CLK _6697_/D VGND VGND VPWR VPWR _6697_/Q sky130_fd_sc_hd__dfxtp_2
XFILLER_40_59 VGND VGND VPWR VPWR sky130_fd_sc_hd__decap_3
X_5648_ _5648_/A _5648_/B VGND VGND VPWR VPWR _5649_/A sky130_fd_sc_hd__or2_2
X_5579_ _5579_/A0 _5045_/X _5595_/B VGND VGND VPWR VPWR _7039_/D sky130_fd_sc_hd__mux2_2
X_7318_ clkload8/A _7318_/D _6598_/Y VGND VGND VPWR VPWR _7318_/Q sky130_fd_sc_hd__dfrtp_2
XFILLER_104_333 VGND VGND VPWR VPWR sky130_fd_sc_hd__decap_3
XFILLER_116_193 VGND VGND VPWR VPWR sky130_fd_sc_hd__decap_3
X_7249_ clkload7/A _7249_/D _6529_/Y VGND VGND VPWR VPWR _7249_/Q sky130_fd_sc_hd__dfrtp_2
XFILLER_104_388 VGND VGND VPWR VPWR sky130_fd_sc_hd__decap_3
XFILLER_49_57 VGND VGND VPWR VPWR sky130_fd_sc_hd__decap_3
XFILLER_58_442 VGND VGND VPWR VPWR sky130_fd_sc_hd__decap_3
XFILLER_58_475 VGND VGND VPWR VPWR sky130_fd_sc_hd__fill_1
XFILLER_65_23 VGND VGND VPWR VPWR sky130_fd_sc_hd__decap_3
XFILLER_100_583 VGND VGND VPWR VPWR sky130_fd_sc_hd__decap_3
XFILLER_105_96 VGND VGND VPWR VPWR sky130_fd_sc_hd__decap_3
XFILLER_45_125 VGND VGND VPWR VPWR sky130_fd_sc_hd__decap_3
XFILLER_46_648 VGND VGND VPWR VPWR sky130_fd_sc_hd__fill_2
XFILLER_46_659 VGND VGND VPWR VPWR sky130_fd_sc_hd__fill_1
XFILLER_73_434 VGND VGND VPWR VPWR sky130_fd_sc_hd__decap_3
XFILLER_33_309 VGND VGND VPWR VPWR sky130_fd_sc_hd__decap_3
XFILLER_45_158 VGND VGND VPWR VPWR sky130_fd_sc_hd__decap_3
XFILLER_65_89 VGND VGND VPWR VPWR sky130_fd_sc_hd__decap_3
XFILLER_73_478 VGND VGND VPWR VPWR sky130_fd_sc_hd__decap_3
XFILLER_26_350 VGND VGND VPWR VPWR sky130_fd_sc_hd__decap_3
XFILLER_60_106 VGND VGND VPWR VPWR sky130_fd_sc_hd__decap_3
XFILLER_60_128 VGND VGND VPWR VPWR sky130_fd_sc_hd__fill_1
XFILLER_41_320 VGND VGND VPWR VPWR sky130_fd_sc_hd__decap_3
XFILLER_60_139 VGND VGND VPWR VPWR sky130_fd_sc_hd__fill_1
XFILLER_81_22 VGND VGND VPWR VPWR sky130_fd_sc_hd__decap_3
XFILLER_81_44 VGND VGND VPWR VPWR sky130_fd_sc_hd__decap_3
XFILLER_14_589 VGND VGND VPWR VPWR sky130_fd_sc_hd__fill_2
XFILLER_81_66 VGND VGND VPWR VPWR sky130_fd_sc_hd__decap_3
XTAP_TAPCELL_ROW_52_871 VGND VPWR sky130_fd_sc_hd__tapvpwrvgnd_1
XTAP_TAPCELL_ROW_24_540 VGND VPWR sky130_fd_sc_hd__tapvpwrvgnd_1
XFILLER_14_71 VGND VGND VPWR VPWR sky130_fd_sc_hd__fill_2
XFILLER_53_9 VGND VGND VPWR VPWR sky130_fd_sc_hd__decap_3
XFILLER_30_70 VGND VGND VPWR VPWR sky130_fd_sc_hd__decap_3
XFILLER_5_265 VGND VGND VPWR VPWR sky130_fd_sc_hd__decap_3
XFILLER_5_287 VGND VGND VPWR VPWR sky130_fd_sc_hd__decap_3
XFILLER_107_193 VGND VGND VPWR VPWR sky130_fd_sc_hd__decap_3
XFILLER_96_504 VGND VGND VPWR VPWR sky130_fd_sc_hd__decap_3
XFILLER_68_206 VGND VGND VPWR VPWR sky130_fd_sc_hd__decap_3
XFILLER_110_325 VGND VGND VPWR VPWR sky130_fd_sc_hd__decap_3
XFILLER_110_358 VGND VGND VPWR VPWR sky130_fd_sc_hd__decap_3
XFILLER_49_431 VGND VGND VPWR VPWR sky130_fd_sc_hd__decap_3
XFILLER_39_90 VGND VGND VPWR VPWR sky130_fd_sc_hd__fill_1
XFILLER_76_250 VGND VGND VPWR VPWR sky130_fd_sc_hd__fill_2
XFILLER_76_261 VGND VGND VPWR VPWR sky130_fd_sc_hd__decap_3
XFILLER_64_412 VGND VGND VPWR VPWR sky130_fd_sc_hd__decap_3
XFILLER_76_294 VGND VGND VPWR VPWR sky130_fd_sc_hd__fill_2
XFILLER_24_309 VGND VGND VPWR VPWR sky130_fd_sc_hd__decap_3
XFILLER_36_158 VGND VGND VPWR VPWR sky130_fd_sc_hd__decap_3
XFILLER_64_456 VGND VGND VPWR VPWR sky130_fd_sc_hd__decap_3
XFILLER_91_231 VGND VGND VPWR VPWR sky130_fd_sc_hd__decap_3
XTAP_TAPCELL_ROW_108_1549 VGND VPWR sky130_fd_sc_hd__tapvpwrvgnd_1
XFILLER_17_361 VGND VGND VPWR VPWR sky130_fd_sc_hd__decap_3
XFILLER_91_297 VGND VGND VPWR VPWR sky130_fd_sc_hd__decap_3
X_4950_ _4950_/A _4950_/B VGND VGND VPWR VPWR _4950_/Y sky130_fd_sc_hd__nor2_2
XFILLER_17_383 VGND VGND VPWR VPWR sky130_fd_sc_hd__decap_3
XFILLER_32_320 VGND VGND VPWR VPWR sky130_fd_sc_hd__decap_3
XFILLER_51_139 VGND VGND VPWR VPWR sky130_fd_sc_hd__decap_3
X_4881_ _6998_/Q _4912_/A VGND VGND VPWR VPWR _4882_/B sky130_fd_sc_hd__or2_2
X_3901_ _3901_/A1 _5104_/A _3900_/Y VGND VGND VPWR VPWR _7381_/D sky130_fd_sc_hd__a21bo_2
X_6620_ _6651_/A VGND VGND VPWR VPWR _6620_/Y sky130_fd_sc_hd__inv_2
X_3832_ _3728_/Y _3824_/X _3826_/X _3735_/X _3831_/X VGND VGND VPWR VPWR _3832_/X
+ sky130_fd_sc_hd__a221o_2
X_6551_ _6617_/A VGND VGND VPWR VPWR _6551_/Y sky130_fd_sc_hd__inv_2
X_3763_ _3763_/A1 _4791_/A1 _3762_/X VGND VGND VPWR VPWR _7395_/D sky130_fd_sc_hd__a21o_2
X_6482_ _6611_/A VGND VGND VPWR VPWR _6482_/Y sky130_fd_sc_hd__inv_2
XFILLER_106_609 VGND VGND VPWR VPWR sky130_fd_sc_hd__decap_3
XFILLER_105_119 VGND VGND VPWR VPWR sky130_fd_sc_hd__decap_3
XFILLER_10_29 VGND VGND VPWR VPWR sky130_fd_sc_hd__decap_3
X_7103_ _7359_/CLK _7103_/D _6383_/Y VGND VGND VPWR VPWR _7103_/Q sky130_fd_sc_hd__dfrtp_2
X_4315_ _4315_/A _4315_/B VGND VGND VPWR VPWR _4361_/A sky130_fd_sc_hd__nand2_2
XFILLER_101_314 VGND VGND VPWR VPWR sky130_fd_sc_hd__fill_2
XFILLER_59_206 VGND VGND VPWR VPWR sky130_fd_sc_hd__decap_3
XFILLER_59_228 VGND VGND VPWR VPWR sky130_fd_sc_hd__fill_2
XFILLER_99_364 VGND VGND VPWR VPWR sky130_fd_sc_hd__decap_3
X_7034_ clkload1/A _7034_/D _6314_/Y VGND VGND VPWR VPWR _7034_/Q sky130_fd_sc_hd__dfrtp_2
X_4246_ _7229_/Q _4262_/A2 _4246_/B1 _7133_/Q VGND VGND VPWR VPWR _4246_/X sky130_fd_sc_hd__a22o_2
XFILLER_101_369 VGND VGND VPWR VPWR sky130_fd_sc_hd__decap_3
XFILLER_19_49 VGND VGND VPWR VPWR sky130_fd_sc_hd__decap_3
XFILLER_95_570 VGND VGND VPWR VPWR sky130_fd_sc_hd__decap_3
X_4177_ _7232_/Q _4262_/A2 _4175_/X _4176_/X VGND VGND VPWR VPWR _4177_/X sky130_fd_sc_hd__a211o_2
XFILLER_27_125 VGND VGND VPWR VPWR sky130_fd_sc_hd__decap_3
XFILLER_55_412 VGND VGND VPWR VPWR sky130_fd_sc_hd__decap_3
XFILLER_27_158 VGND VGND VPWR VPWR sky130_fd_sc_hd__decap_3
XFILLER_55_445 VGND VGND VPWR VPWR sky130_fd_sc_hd__decap_3
XFILLER_55_467 VGND VGND VPWR VPWR sky130_fd_sc_hd__decap_3
XFILLER_82_253 VGND VGND VPWR VPWR sky130_fd_sc_hd__decap_3
XTAP_TAPCELL_ROW_2_279 VGND VPWR sky130_fd_sc_hd__tapvpwrvgnd_1
XFILLER_27_169 VGND VGND VPWR VPWR sky130_fd_sc_hd__decap_3
XFILLER_42_106 VGND VGND VPWR VPWR sky130_fd_sc_hd__decap_3
XFILLER_70_415 VGND VGND VPWR VPWR sky130_fd_sc_hd__decap_3
XFILLER_70_459 VGND VGND VPWR VPWR sky130_fd_sc_hd__decap_3
XFILLER_23_375 VGND VGND VPWR VPWR sky130_fd_sc_hd__fill_2
XFILLER_51_673 VGND VGND VPWR VPWR sky130_fd_sc_hd__fill_2
X_6818_ _6976_/CLK _6818_/D VGND VGND VPWR VPWR _6818_/Q sky130_fd_sc_hd__dfxtp_2
XFILLER_50_183 VGND VGND VPWR VPWR sky130_fd_sc_hd__decap_3
X_6749_ _6965_/CLK _6749_/D VGND VGND VPWR VPWR _6749_/Q sky130_fd_sc_hd__dfxtp_2
XTAP_TAPCELL_ROW_98_1431 VGND VPWR sky130_fd_sc_hd__tapvpwrvgnd_1
XFILLER_109_458 VGND VGND VPWR VPWR sky130_fd_sc_hd__decap_3
XFILLER_109_469 VGND VGND VPWR VPWR sky130_fd_sc_hd__fill_2
XFILLER_2_213 VGND VGND VPWR VPWR sky130_fd_sc_hd__decap_3
XFILLER_2_246 VGND VGND VPWR VPWR sky130_fd_sc_hd__decap_3
XFILLER_104_141 VGND VGND VPWR VPWR sky130_fd_sc_hd__fill_1
XFILLER_76_44 VGND VGND VPWR VPWR sky130_fd_sc_hd__decap_3
XFILLER_100_380 VGND VGND VPWR VPWR sky130_fd_sc_hd__decap_3
XFILLER_19_637 VGND VGND VPWR VPWR sky130_fd_sc_hd__fill_1
XFILLER_58_294 VGND VGND VPWR VPWR sky130_fd_sc_hd__decap_3
XFILLER_76_77 VGND VGND VPWR VPWR sky130_fd_sc_hd__decap_3
XFILLER_86_592 VGND VGND VPWR VPWR sky130_fd_sc_hd__decap_3
XTAP_TAPCELL_ROW_57_930 VGND VPWR sky130_fd_sc_hd__tapvpwrvgnd_1
XFILLER_18_136 VGND VGND VPWR VPWR sky130_fd_sc_hd__decap_3
XFILLER_46_445 VGND VGND VPWR VPWR sky130_fd_sc_hd__decap_3
XFILLER_73_231 VGND VGND VPWR VPWR sky130_fd_sc_hd__decap_3
XTAP_TAPCELL_ROW_57_941 VGND VPWR sky130_fd_sc_hd__tapvpwrvgnd_1
XFILLER_18_169 VGND VGND VPWR VPWR sky130_fd_sc_hd__decap_3
XFILLER_73_275 VGND VGND VPWR VPWR sky130_fd_sc_hd__decap_3
XFILLER_92_32 VGND VGND VPWR VPWR sky130_fd_sc_hd__decap_3
XFILLER_26_191 VGND VGND VPWR VPWR sky130_fd_sc_hd__decap_3
XFILLER_92_76 VGND VGND VPWR VPWR sky130_fd_sc_hd__decap_3
XFILLER_14_342 VGND VGND VPWR VPWR sky130_fd_sc_hd__fill_2
XFILLER_14_353 VGND VGND VPWR VPWR sky130_fd_sc_hd__decap_3
XFILLER_25_81 VGND VGND VPWR VPWR sky130_fd_sc_hd__decap_3
XFILLER_41_150 VGND VGND VPWR VPWR sky130_fd_sc_hd__decap_3
XFILLER_42_662 VGND VGND VPWR VPWR sky130_fd_sc_hd__decap_3
XFILLER_41_172 VGND VGND VPWR VPWR sky130_fd_sc_hd__decap_3
XFILLER_115_417 VGND VGND VPWR VPWR sky130_fd_sc_hd__decap_3
XFILLER_51_6 VGND VGND VPWR VPWR sky130_fd_sc_hd__decap_3
XTAP_TAPCELL_ROW_71_1103 VGND VPWR sky130_fd_sc_hd__tapvpwrvgnd_1
XFILLER_111_612 VGND VGND VPWR VPWR sky130_fd_sc_hd__decap_3
XFILLER_69_526 VGND VGND VPWR VPWR sky130_fd_sc_hd__decap_3
XFILLER_96_301 VGND VGND VPWR VPWR sky130_fd_sc_hd__decap_3
XFILLER_96_312 VGND VGND VPWR VPWR sky130_fd_sc_hd__decap_3
XFILLER_69_559 VGND VGND VPWR VPWR sky130_fd_sc_hd__fill_1
XFILLER_96_345 VGND VGND VPWR VPWR sky130_fd_sc_hd__decap_3
X_5080_ hold999/X _5079_/X _5080_/S VGND VGND VPWR VPWR _7257_/D sky130_fd_sc_hd__mux2_2
X_4100_ _7269_/Q _4422_/A2 _4349_/B1 _7237_/Q _4099_/X VGND VGND VPWR VPWR _4100_/X
+ sky130_fd_sc_hd__a221o_2
XFILLER_111_689 VGND VGND VPWR VPWR sky130_fd_sc_hd__decap_3
XFILLER_1_290 VGND VGND VPWR VPWR sky130_fd_sc_hd__decap_3
XFILLER_2_52 VGND VGND VPWR VPWR sky130_fd_sc_hd__decap_3
XFILLER_49_250 VGND VGND VPWR VPWR sky130_fd_sc_hd__decap_3
XFILLER_56_209 VGND VGND VPWR VPWR sky130_fd_sc_hd__decap_3
XFILLER_84_507 VGND VGND VPWR VPWR sky130_fd_sc_hd__decap_3
XFILLER_96_389 VGND VGND VPWR VPWR sky130_fd_sc_hd__fill_2
XFILLER_37_423 VGND VGND VPWR VPWR sky130_fd_sc_hd__fill_2
XFILLER_49_272 VGND VGND VPWR VPWR sky130_fd_sc_hd__decap_3
XFILLER_77_592 VGND VGND VPWR VPWR sky130_fd_sc_hd__decap_3
XFILLER_37_445 VGND VGND VPWR VPWR sky130_fd_sc_hd__decap_3
XFILLER_37_467 VGND VGND VPWR VPWR sky130_fd_sc_hd__fill_2
XFILLER_64_220 VGND VGND VPWR VPWR sky130_fd_sc_hd__decap_3
XFILLER_64_231 VGND VGND VPWR VPWR sky130_fd_sc_hd__decap_3
XFILLER_92_551 VGND VGND VPWR VPWR sky130_fd_sc_hd__decap_3
XFILLER_37_489 VGND VGND VPWR VPWR sky130_fd_sc_hd__decap_3
XTAP_TAPCELL_ROW_69_1076 VGND VPWR sky130_fd_sc_hd__tapvpwrvgnd_1
XFILLER_52_448 VGND VGND VPWR VPWR sky130_fd_sc_hd__decap_3
X_4933_ _4933_/A0 _4932_/X _4946_/S VGND VGND VPWR VPWR _7266_/D sky130_fd_sc_hd__mux2_2
XTAP_TAPCELL_ROW_82_1232 VGND VPWR sky130_fd_sc_hd__tapvpwrvgnd_1
XFILLER_32_150 VGND VGND VPWR VPWR sky130_fd_sc_hd__decap_3
XFILLER_33_662 VGND VGND VPWR VPWR sky130_fd_sc_hd__fill_2
XTAP_TAPCELL_ROW_35_668 VGND VPWR sky130_fd_sc_hd__tapvpwrvgnd_1
XANTENNA_13 _5217_/B VGND VGND VPWR VPWR sky130_fd_sc_hd__diode_2
XFILLER_20_301 VGND VGND VPWR VPWR sky130_fd_sc_hd__decap_3
XFILLER_60_492 VGND VGND VPWR VPWR sky130_fd_sc_hd__decap_3
X_4864_ _5092_/C _4857_/X _4860_/Y _7000_/D _4997_/A1 VGND VGND VPWR VPWR _4864_/X
+ sky130_fd_sc_hd__a32o_2
XANTENNA_24 _3556_/A VGND VGND VPWR VPWR sky130_fd_sc_hd__diode_2
XFILLER_20_345 VGND VGND VPWR VPWR sky130_fd_sc_hd__decap_3
XFILLER_32_194 VGND VGND VPWR VPWR sky130_fd_sc_hd__fill_2
X_6603_ _6632_/A VGND VGND VPWR VPWR _6603_/Y sky130_fd_sc_hd__inv_2
X_4795_ _4795_/A _4795_/B VGND VGND VPWR VPWR _4795_/X sky130_fd_sc_hd__xor2_2
X_3815_ _6928_/Q _3859_/A2 _3863_/A2 _6702_/Q VGND VGND VPWR VPWR _3815_/X sky130_fd_sc_hd__a22o_2
X_6534_ _6568_/A VGND VGND VPWR VPWR _6534_/Y sky130_fd_sc_hd__inv_2
X_3746_ _3746_/A _3746_/B _3746_/C VGND VGND VPWR VPWR _3746_/X sky130_fd_sc_hd__and3_2
X_6465_ _6660_/A VGND VGND VPWR VPWR _6465_/Y sky130_fd_sc_hd__inv_2
XFILLER_106_439 VGND VGND VPWR VPWR sky130_fd_sc_hd__decap_3
X_3677_ _6942_/Q VGND VGND VPWR VPWR _3677_/Y sky130_fd_sc_hd__inv_2
X_6396_ _6651_/A VGND VGND VPWR VPWR _6396_/Y sky130_fd_sc_hd__inv_2
XFILLER_102_612 VGND VGND VPWR VPWR sky130_fd_sc_hd__decap_3
XTAP_TAPCELL_ROW_93_1372 VGND VPWR sky130_fd_sc_hd__tapvpwrvgnd_1
XTAP_TAPCELL_ROW_7_338 VGND VPWR sky130_fd_sc_hd__tapvpwrvgnd_1
XFILLER_101_111 VGND VGND VPWR VPWR sky130_fd_sc_hd__fill_1
XFILLER_102_645 VGND VGND VPWR VPWR sky130_fd_sc_hd__decap_3
XFILLER_87_323 VGND VGND VPWR VPWR sky130_fd_sc_hd__decap_3
X_5278_ _5278_/A0 _5107_/X _5292_/S VGND VGND VPWR VPWR _7191_/D sky130_fd_sc_hd__mux2_2
XFILLER_87_367 VGND VGND VPWR VPWR sky130_fd_sc_hd__decap_3
X_7017_ _7361_/CLK _7017_/D _6297_/Y VGND VGND VPWR VPWR _7017_/Q sky130_fd_sc_hd__dfrtp_2
X_4229_ _7099_/Q _4351_/A2 _4351_/B1 _7131_/Q VGND VGND VPWR VPWR _4229_/X sky130_fd_sc_hd__a22o_2
XFILLER_28_412 VGND VGND VPWR VPWR sky130_fd_sc_hd__decap_3
XFILLER_68_581 VGND VGND VPWR VPWR sky130_fd_sc_hd__decap_3
XFILLER_28_467 VGND VGND VPWR VPWR sky130_fd_sc_hd__decap_3
XFILLER_46_58 VGND VGND VPWR VPWR sky130_fd_sc_hd__decap_3
XFILLER_55_231 VGND VGND VPWR VPWR sky130_fd_sc_hd__decap_3
XFILLER_15_106 VGND VGND VPWR VPWR sky130_fd_sc_hd__decap_3
XFILLER_83_573 VGND VGND VPWR VPWR sky130_fd_sc_hd__decap_3
XTAP_TAPCELL_ROW_54_900 VGND VPWR sky130_fd_sc_hd__tapvpwrvgnd_1
XFILLER_70_223 VGND VGND VPWR VPWR sky130_fd_sc_hd__decap_3
XFILLER_24_640 VGND VGND VPWR VPWR sky130_fd_sc_hd__decap_3
XFILLER_62_24 VGND VGND VPWR VPWR sky130_fd_sc_hd__decap_3
XFILLER_62_35 VGND VGND VPWR VPWR sky130_fd_sc_hd__decap_3
XFILLER_70_256 VGND VGND VPWR VPWR sky130_fd_sc_hd__decap_3
XFILLER_23_172 VGND VGND VPWR VPWR sky130_fd_sc_hd__decap_3
XFILLER_51_470 VGND VGND VPWR VPWR sky130_fd_sc_hd__decap_3
XFILLER_7_305 VGND VGND VPWR VPWR sky130_fd_sc_hd__decap_3
XFILLER_109_200 VGND VGND VPWR VPWR sky130_fd_sc_hd__decap_3
XFILLER_11_367 VGND VGND VPWR VPWR sky130_fd_sc_hd__decap_3
XFILLER_109_255 VGND VGND VPWR VPWR sky130_fd_sc_hd__decap_3
XFILLER_3_555 VGND VGND VPWR VPWR sky130_fd_sc_hd__decap_3
XFILLER_105_461 VGND VGND VPWR VPWR sky130_fd_sc_hd__decap_3
XFILLER_87_21 VGND VGND VPWR VPWR sky130_fd_sc_hd__decap_3
XFILLER_97_109 VGND VGND VPWR VPWR sky130_fd_sc_hd__decap_3
XFILLER_78_312 VGND VGND VPWR VPWR sky130_fd_sc_hd__decap_3
XFILLER_66_507 VGND VGND VPWR VPWR sky130_fd_sc_hd__decap_3
XFILLER_87_87 VGND VGND VPWR VPWR sky130_fd_sc_hd__decap_3
XFILLER_93_304 VGND VGND VPWR VPWR sky130_fd_sc_hd__decap_3
XFILLER_16_9 VGND VGND VPWR VPWR sky130_fd_sc_hd__decap_3
XFILLER_19_423 VGND VGND VPWR VPWR sky130_fd_sc_hd__decap_3
XFILLER_78_389 VGND VGND VPWR VPWR sky130_fd_sc_hd__decap_3
XFILLER_93_337 VGND VGND VPWR VPWR sky130_fd_sc_hd__decap_3
XFILLER_74_551 VGND VGND VPWR VPWR sky130_fd_sc_hd__decap_3
XFILLER_46_253 VGND VGND VPWR VPWR sky130_fd_sc_hd__decap_3
XFILLER_74_584 VGND VGND VPWR VPWR sky130_fd_sc_hd__decap_3
XTAP_TAPCELL_ROW_105_1508 VGND VPWR sky130_fd_sc_hd__tapvpwrvgnd_1
XFILLER_36_91 VGND VGND VPWR VPWR sky130_fd_sc_hd__decap_3
XFILLER_61_223 VGND VGND VPWR VPWR sky130_fd_sc_hd__fill_1
XFILLER_61_234 VGND VGND VPWR VPWR sky130_fd_sc_hd__decap_3
XFILLER_74_595 VGND VGND VPWR VPWR sky130_fd_sc_hd__decap_3
XFILLER_61_256 VGND VGND VPWR VPWR sky130_fd_sc_hd__decap_3
XFILLER_14_150 VGND VGND VPWR VPWR sky130_fd_sc_hd__fill_2
XFILLER_14_161 VGND VGND VPWR VPWR sky130_fd_sc_hd__fill_2
XTAP_TAPCELL_ROW_32_638 VGND VPWR sky130_fd_sc_hd__tapvpwrvgnd_1
XFILLER_99_6 VGND VGND VPWR VPWR sky130_fd_sc_hd__decap_3
XFILLER_30_643 VGND VGND VPWR VPWR sky130_fd_sc_hd__fill_1
XTAP_TAPCELL_ROW_60_969 VGND VPWR sky130_fd_sc_hd__tapvpwrvgnd_1
X_3600_ _3600_/A VGND VGND VPWR VPWR _3600_/Y sky130_fd_sc_hd__inv_2
XTAP_TAPCELL_ROW_12_395 VGND VPWR sky130_fd_sc_hd__tapvpwrvgnd_1
Xhold806 _6777_/Q VGND VGND VPWR VPWR _6777_/D sky130_fd_sc_hd__dlygate4sd3_1
Xhold817 _6788_/Q VGND VGND VPWR VPWR _6788_/D sky130_fd_sc_hd__dlygate4sd3_1
Xhold828 _6833_/Q VGND VGND VPWR VPWR _6833_/D sky130_fd_sc_hd__dlygate4sd3_1
XTAP_TAPCELL_ROW_116_1648 VGND VPWR sky130_fd_sc_hd__tapvpwrvgnd_1
XFILLER_115_225 VGND VGND VPWR VPWR sky130_fd_sc_hd__decap_3
Xhold839 _6760_/Q VGND VGND VPWR VPWR _6760_/D sky130_fd_sc_hd__dlygate4sd3_1
Xmax_cap558 _5047_/Y VGND VGND VPWR VPWR _5084_/B sky130_fd_sc_hd__buf_1
X_3462_ _7249_/Q _4601_/S _3459_/X _3461_/X VGND VGND VPWR VPWR _3462_/X sky130_fd_sc_hd__a211o_2
XTAP_TAPCELL_ROW_116_1659 VGND VPWR sky130_fd_sc_hd__tapvpwrvgnd_1
XFILLER_111_420 VGND VGND VPWR VPWR sky130_fd_sc_hd__fill_1
XFILLER_69_312 VGND VGND VPWR VPWR sky130_fd_sc_hd__fill_2
XFILLER_69_334 VGND VGND VPWR VPWR sky130_fd_sc_hd__fill_2
XFILLER_97_632 VGND VGND VPWR VPWR sky130_fd_sc_hd__decap_3
X_5132_ _5132_/A0 _5131_/X _5132_/S VGND VGND VPWR VPWR _7252_/D sky130_fd_sc_hd__mux2_2
XFILLER_69_345 VGND VGND VPWR VPWR sky130_fd_sc_hd__decap_3
XFILLER_69_378 VGND VGND VPWR VPWR sky130_fd_sc_hd__decap_3
XFILLER_96_153 VGND VGND VPWR VPWR sky130_fd_sc_hd__decap_3
XFILLER_84_315 VGND VGND VPWR VPWR sky130_fd_sc_hd__fill_1
XFILLER_84_326 VGND VGND VPWR VPWR sky130_fd_sc_hd__decap_3
XFILLER_96_186 VGND VGND VPWR VPWR sky130_fd_sc_hd__decap_3
XFILLER_96_197 VGND VGND VPWR VPWR sky130_fd_sc_hd__decap_3
X_5063_ hold989/X _5061_/X _5132_/S VGND VGND VPWR VPWR _7258_/D sky130_fd_sc_hd__mux2_2
XFILLER_37_231 VGND VGND VPWR VPWR sky130_fd_sc_hd__decap_3
XFILLER_65_540 VGND VGND VPWR VPWR sky130_fd_sc_hd__decap_3
XFILLER_37_275 VGND VGND VPWR VPWR sky130_fd_sc_hd__decap_3
XFILLER_80_510 VGND VGND VPWR VPWR sky130_fd_sc_hd__decap_3
XFILLER_52_256 VGND VGND VPWR VPWR sky130_fd_sc_hd__decap_3
XFILLER_80_554 VGND VGND VPWR VPWR sky130_fd_sc_hd__fill_2
XFILLER_33_481 VGND VGND VPWR VPWR sky130_fd_sc_hd__decap_3
XFILLER_80_587 VGND VGND VPWR VPWR sky130_fd_sc_hd__fill_1
XFILLER_80_598 VGND VGND VPWR VPWR sky130_fd_sc_hd__decap_3
X_4916_ _4916_/A _4916_/B VGND VGND VPWR VPWR _4967_/A sky130_fd_sc_hd__nand2_2
XFILLER_20_120 VGND VGND VPWR VPWR sky130_fd_sc_hd__decap_3
X_4847_ _4968_/A _4384_/C _4206_/X VGND VGND VPWR VPWR _4904_/B sky130_fd_sc_hd__a21oi_2
X_4778_ _4778_/A _4778_/B VGND VGND VPWR VPWR _4827_/B sky130_fd_sc_hd__and2_2
XFILLER_106_203 VGND VGND VPWR VPWR sky130_fd_sc_hd__decap_3
X_6517_ _6642_/A VGND VGND VPWR VPWR _6517_/Y sky130_fd_sc_hd__inv_2
X_3729_ _6968_/Q _3869_/A2 _3881_/B1 _6962_/Q VGND VGND VPWR VPWR _3729_/X sky130_fd_sc_hd__a22o_2
XFILLER_106_225 VGND VGND VPWR VPWR sky130_fd_sc_hd__decap_3
X_6448_ _6608_/A VGND VGND VPWR VPWR _6448_/Y sky130_fd_sc_hd__inv_2
X_6379_ _6568_/A VGND VGND VPWR VPWR _6379_/Y sky130_fd_sc_hd__inv_2
XFILLER_87_120 VGND VGND VPWR VPWR sky130_fd_sc_hd__decap_3
XFILLER_88_643 VGND VGND VPWR VPWR sky130_fd_sc_hd__fill_1
XFILLER_102_464 VGND VGND VPWR VPWR sky130_fd_sc_hd__decap_3
XFILLER_57_24 VGND VGND VPWR VPWR sky130_fd_sc_hd__decap_3
XFILLER_88_665 VGND VGND VPWR VPWR sky130_fd_sc_hd__decap_3
XFILLER_57_57 VGND VGND VPWR VPWR sky130_fd_sc_hd__decap_3
XFILLER_75_337 VGND VGND VPWR VPWR sky130_fd_sc_hd__decap_3
XFILLER_28_231 VGND VGND VPWR VPWR sky130_fd_sc_hd__decap_3
XFILLER_87_197 VGND VGND VPWR VPWR sky130_fd_sc_hd__decap_3
XFILLER_113_63 VGND VGND VPWR VPWR sky130_fd_sc_hd__decap_3
XFILLER_28_253 VGND VGND VPWR VPWR sky130_fd_sc_hd__decap_3
XFILLER_90_307 VGND VGND VPWR VPWR sky130_fd_sc_hd__fill_1
XFILLER_90_318 VGND VGND VPWR VPWR sky130_fd_sc_hd__decap_3
XFILLER_113_96 VGND VGND VPWR VPWR sky130_fd_sc_hd__decap_3
XFILLER_16_448 VGND VGND VPWR VPWR sky130_fd_sc_hd__decap_3
XFILLER_71_543 VGND VGND VPWR VPWR sky130_fd_sc_hd__decap_3
XFILLER_73_34 VGND VGND VPWR VPWR sky130_fd_sc_hd__decap_3
XFILLER_83_370 VGND VGND VPWR VPWR sky130_fd_sc_hd__decap_3
XFILLER_43_245 VGND VGND VPWR VPWR sky130_fd_sc_hd__decap_3
XFILLER_71_576 VGND VGND VPWR VPWR sky130_fd_sc_hd__decap_3
XFILLER_31_418 VGND VGND VPWR VPWR sky130_fd_sc_hd__decap_3
XFILLER_43_278 VGND VGND VPWR VPWR sky130_fd_sc_hd__fill_2
XFILLER_11_131 VGND VGND VPWR VPWR sky130_fd_sc_hd__decap_3
XFILLER_12_654 VGND VGND VPWR VPWR sky130_fd_sc_hd__fill_1
XTAP_TAPCELL_ROW_100_1449 VGND VPWR sky130_fd_sc_hd__tapvpwrvgnd_1
XFILLER_11_164 VGND VGND VPWR VPWR sky130_fd_sc_hd__decap_3
XFILLER_11_175 VGND VGND VPWR VPWR sky130_fd_sc_hd__decap_3
XFILLER_7_157 VGND VGND VPWR VPWR sky130_fd_sc_hd__decap_3
XFILLER_22_71 VGND VGND VPWR VPWR sky130_fd_sc_hd__decap_3
XFILLER_3_330 VGND VGND VPWR VPWR sky130_fd_sc_hd__decap_3
XFILLER_98_42 VGND VGND VPWR VPWR sky130_fd_sc_hd__decap_3
XFILLER_112_206 VGND VGND VPWR VPWR sky130_fd_sc_hd__decap_3
XFILLER_3_363 VGND VGND VPWR VPWR sky130_fd_sc_hd__decap_3
XFILLER_79_610 VGND VGND VPWR VPWR sky130_fd_sc_hd__decap_3
XFILLER_98_75 VGND VGND VPWR VPWR sky130_fd_sc_hd__decap_3
XFILLER_98_418 VGND VGND VPWR VPWR sky130_fd_sc_hd__fill_2
XFILLER_3_396 VGND VGND VPWR VPWR sky130_fd_sc_hd__decap_3
XFILLER_79_632 VGND VGND VPWR VPWR sky130_fd_sc_hd__decap_3
XTAP_TAPCELL_ROW_111_1578 VGND VPWR sky130_fd_sc_hd__tapvpwrvgnd_1
XFILLER_66_304 VGND VGND VPWR VPWR sky130_fd_sc_hd__decap_3
XFILLER_66_326 VGND VGND VPWR VPWR sky130_fd_sc_hd__decap_3
XFILLER_78_164 VGND VGND VPWR VPWR sky130_fd_sc_hd__decap_3
XFILLER_94_624 VGND VGND VPWR VPWR sky130_fd_sc_hd__decap_3
XTAP_TAPCELL_ROW_111_1589 VGND VPWR sky130_fd_sc_hd__tapvpwrvgnd_1
XFILLER_14_6 VGND VGND VPWR VPWR sky130_fd_sc_hd__fill_2
XFILLER_19_231 VGND VGND VPWR VPWR sky130_fd_sc_hd__decap_3
XFILLER_66_359 VGND VGND VPWR VPWR sky130_fd_sc_hd__decap_3
XFILLER_78_197 VGND VGND VPWR VPWR sky130_fd_sc_hd__decap_3
XFILLER_94_657 VGND VGND VPWR VPWR sky130_fd_sc_hd__fill_1
XFILLER_19_264 VGND VGND VPWR VPWR sky130_fd_sc_hd__decap_3
XFILLER_81_329 VGND VGND VPWR VPWR sky130_fd_sc_hd__decap_3
XFILLER_93_167 VGND VGND VPWR VPWR sky130_fd_sc_hd__fill_1
XFILLER_93_178 VGND VGND VPWR VPWR sky130_fd_sc_hd__fill_2
XFILLER_22_407 VGND VGND VPWR VPWR sky130_fd_sc_hd__decap_3
XFILLER_34_256 VGND VGND VPWR VPWR sky130_fd_sc_hd__decap_3
XFILLER_62_565 VGND VGND VPWR VPWR sky130_fd_sc_hd__decap_3
XTAP_TAPCELL_ROW_66_1046 VGND VPWR sky130_fd_sc_hd__tapvpwrvgnd_1
XTAP_TAPCELL_ROW_17_454 VGND VPWR sky130_fd_sc_hd__tapvpwrvgnd_1
XFILLER_34_289 VGND VGND VPWR VPWR sky130_fd_sc_hd__decap_3
XFILLER_97_3 VGND VGND VPWR VPWR sky130_fd_sc_hd__decap_3
XTAP_TAPCELL_ROW_45_796 VGND VPWR sky130_fd_sc_hd__tapvpwrvgnd_1
X_4701_ _6989_/Q _6990_/Q _5044_/A VGND VGND VPWR VPWR _5026_/A sky130_fd_sc_hd__and3_2
X_4632_ _4626_/X _4274_/Y _4631_/X VGND VGND VPWR VPWR _4916_/B sky130_fd_sc_hd__a21oi_2
XFILLER_30_495 VGND VGND VPWR VPWR sky130_fd_sc_hd__decap_3
X_7351_ _7351_/CLK _7351_/D _6631_/Y VGND VGND VPWR VPWR _7351_/Q sky130_fd_sc_hd__dfrtp_2
Xhold603 _6898_/Q VGND VGND VPWR VPWR _6898_/D sky130_fd_sc_hd__dlygate4sd3_1
X_4563_ _4563_/A _4567_/B VGND VGND VPWR VPWR _7299_/D sky130_fd_sc_hd__and2_2
XFILLER_116_545 VGND VGND VPWR VPWR sky130_fd_sc_hd__decap_3
X_7282_ clkload8/A _7282_/D _6562_/Y VGND VGND VPWR VPWR _7282_/Q sky130_fd_sc_hd__dfrtp_2
Xhold614 _6875_/Q VGND VGND VPWR VPWR _6875_/D sky130_fd_sc_hd__dlygate4sd3_1
Xhold625 _6816_/Q VGND VGND VPWR VPWR _6816_/D sky130_fd_sc_hd__dlygate4sd3_1
Xhold636 _6880_/Q VGND VGND VPWR VPWR _6880_/D sky130_fd_sc_hd__dlygate4sd3_1
X_6302_ _6553_/A VGND VGND VPWR VPWR _6302_/Y sky130_fd_sc_hd__inv_2
XFILLER_6_190 VGND VGND VPWR VPWR sky130_fd_sc_hd__decap_3
XFILLER_89_429 VGND VGND VPWR VPWR sky130_fd_sc_hd__decap_3
Xhold647 _6830_/Q VGND VGND VPWR VPWR _6830_/D sky130_fd_sc_hd__dlygate4sd3_1
Xhold658 _6725_/Q VGND VGND VPWR VPWR _6725_/D sky130_fd_sc_hd__dlygate4sd3_1
Xhold669 _6836_/Q VGND VGND VPWR VPWR _6836_/D sky130_fd_sc_hd__dlygate4sd3_1
XTAP_TAPCELL_ROW_77_1175 VGND VPWR sky130_fd_sc_hd__tapvpwrvgnd_1
XFILLER_103_217 VGND VGND VPWR VPWR sky130_fd_sc_hd__decap_3
XFILLER_103_228 VGND VGND VPWR VPWR sky130_fd_sc_hd__decap_3
XTAP_TAPCELL_ROW_90_1331 VGND VPWR sky130_fd_sc_hd__tapvpwrvgnd_1
XFILLER_69_131 VGND VGND VPWR VPWR sky130_fd_sc_hd__decap_3
X_3376_ _3376_/A _3376_/B VGND VGND VPWR VPWR _3376_/Y sky130_fd_sc_hd__nor2_2
XFILLER_111_250 VGND VGND VPWR VPWR sky130_fd_sc_hd__decap_3
XFILLER_57_326 VGND VGND VPWR VPWR sky130_fd_sc_hd__decap_3
XFILLER_69_175 VGND VGND VPWR VPWR sky130_fd_sc_hd__decap_3
XFILLER_84_112 VGND VGND VPWR VPWR sky130_fd_sc_hd__decap_3
XFILLER_85_613 VGND VGND VPWR VPWR sky130_fd_sc_hd__decap_3
XFILLER_97_473 VGND VGND VPWR VPWR sky130_fd_sc_hd__decap_3
X_5115_ _5101_/A _4292_/C _5113_/Y _5020_/A _5114_/Y VGND VGND VPWR VPWR _5115_/X
+ sky130_fd_sc_hd__o221a_2
XFILLER_57_337 VGND VGND VPWR VPWR sky130_fd_sc_hd__decap_3
XFILLER_85_646 VGND VGND VPWR VPWR sky130_fd_sc_hd__decap_3
X_5046_ _5101_/B VGND VGND VPWR VPWR _5100_/A sky130_fd_sc_hd__inv_2
XFILLER_72_307 VGND VGND VPWR VPWR sky130_fd_sc_hd__fill_1
XFILLER_72_318 VGND VGND VPWR VPWR sky130_fd_sc_hd__decap_3
XFILLER_85_679 VGND VGND VPWR VPWR sky130_fd_sc_hd__decap_3
XFILLER_25_223 VGND VGND VPWR VPWR sky130_fd_sc_hd__fill_1
XFILLER_65_370 VGND VGND VPWR VPWR sky130_fd_sc_hd__decap_3
XFILLER_13_407 VGND VGND VPWR VPWR sky130_fd_sc_hd__decap_3
XFILLER_25_245 VGND VGND VPWR VPWR sky130_fd_sc_hd__decap_3
XFILLER_53_543 VGND VGND VPWR VPWR sky130_fd_sc_hd__decap_3
X_6997_ _7368_/CLK _6997_/D _6277_/Y VGND VGND VPWR VPWR _6997_/Q sky130_fd_sc_hd__dfrtp_2
XFILLER_25_278 VGND VGND VPWR VPWR sky130_fd_sc_hd__fill_2
XFILLER_40_226 VGND VGND VPWR VPWR sky130_fd_sc_hd__decap_3
XFILLER_43_26 VGND VGND VPWR VPWR sky130_fd_sc_hd__decap_3
XFILLER_80_362 VGND VGND VPWR VPWR sky130_fd_sc_hd__fill_2
XFILLER_40_259 VGND VGND VPWR VPWR sky130_fd_sc_hd__decap_3
XFILLER_5_617 VGND VGND VPWR VPWR sky130_fd_sc_hd__fill_1
XFILLER_5_639 VGND VGND VPWR VPWR sky130_fd_sc_hd__decap_3
XFILLER_107_534 VGND VGND VPWR VPWR sky130_fd_sc_hd__decap_3
XFILLER_4_138 VGND VGND VPWR VPWR sky130_fd_sc_hd__fill_2
XFILLER_108_41 VGND VGND VPWR VPWR sky130_fd_sc_hd__decap_3
XFILLER_108_85 VGND VGND VPWR VPWR sky130_fd_sc_hd__decap_3
XFILLER_0_333 VGND VGND VPWR VPWR sky130_fd_sc_hd__decap_3
XFILLER_68_56 VGND VGND VPWR VPWR sky130_fd_sc_hd__decap_3
XFILLER_102_250 VGND VGND VPWR VPWR sky130_fd_sc_hd__fill_2
XFILLER_48_315 VGND VGND VPWR VPWR sky130_fd_sc_hd__decap_3
XFILLER_88_495 VGND VGND VPWR VPWR sky130_fd_sc_hd__decap_3
XFILLER_0_399 VGND VGND VPWR VPWR sky130_fd_sc_hd__fill_2
XFILLER_102_294 VGND VGND VPWR VPWR sky130_fd_sc_hd__decap_3
XFILLER_29_540 VGND VGND VPWR VPWR sky130_fd_sc_hd__decap_3
XFILLER_48_348 VGND VGND VPWR VPWR sky130_fd_sc_hd__fill_2
XFILLER_48_359 VGND VGND VPWR VPWR sky130_fd_sc_hd__fill_2
XFILLER_75_123 VGND VGND VPWR VPWR sky130_fd_sc_hd__decap_3
XFILLER_75_145 VGND VGND VPWR VPWR sky130_fd_sc_hd__decap_3
XFILLER_75_178 VGND VGND VPWR VPWR sky130_fd_sc_hd__decap_3
XFILLER_29_595 VGND VGND VPWR VPWR sky130_fd_sc_hd__decap_3
XFILLER_63_329 VGND VGND VPWR VPWR sky130_fd_sc_hd__decap_3
XFILLER_90_115 VGND VGND VPWR VPWR sky130_fd_sc_hd__decap_3
XFILLER_90_137 VGND VGND VPWR VPWR sky130_fd_sc_hd__decap_3
Xplace318 _4327_/A VGND VGND VPWR VPWR _4425_/A sky130_fd_sc_hd__buf_2
Xplace307 _3605_/Y VGND VGND VPWR VPWR _4811_/C sky130_fd_sc_hd__buf_2
XFILLER_16_245 VGND VGND VPWR VPWR sky130_fd_sc_hd__decap_3
XFILLER_16_256 VGND VGND VPWR VPWR sky130_fd_sc_hd__decap_3
XFILLER_17_60 VGND VGND VPWR VPWR sky130_fd_sc_hd__decap_3
XFILLER_17_82 VGND VGND VPWR VPWR sky130_fd_sc_hd__decap_3
Xplace329 _5729_/S VGND VGND VPWR VPWR _5737_/S sky130_fd_sc_hd__buf_2
XFILLER_16_289 VGND VGND VPWR VPWR sky130_fd_sc_hd__decap_3
XFILLER_31_215 VGND VGND VPWR VPWR sky130_fd_sc_hd__decap_3
XFILLER_31_248 VGND VGND VPWR VPWR sky130_fd_sc_hd__decap_3
XTAP_TAPCELL_ROW_42_755 VGND VPWR sky130_fd_sc_hd__tapvpwrvgnd_1
XTAP_TAPCELL_ROW_14_424 VGND VPWR sky130_fd_sc_hd__tapvpwrvgnd_1
XFILLER_8_477 VGND VGND VPWR VPWR sky130_fd_sc_hd__decap_3
XTAP_TAPCELL_ROW_113_1607 VGND VPWR sky130_fd_sc_hd__tapvpwrvgnd_1
XFILLER_113_526 VGND VGND VPWR VPWR sky130_fd_sc_hd__fill_1
XFILLER_113_548 VGND VGND VPWR VPWR sky130_fd_sc_hd__decap_3
XFILLER_3_160 VGND VGND VPWR VPWR sky130_fd_sc_hd__decap_3
XFILLER_79_473 VGND VGND VPWR VPWR sky130_fd_sc_hd__decap_3
XFILLER_12_3 VGND VGND VPWR VPWR sky130_fd_sc_hd__decap_3
XFILLER_39_337 VGND VGND VPWR VPWR sky130_fd_sc_hd__decap_3
XFILLER_66_112 VGND VGND VPWR VPWR sky130_fd_sc_hd__fill_1
XFILLER_66_134 VGND VGND VPWR VPWR sky130_fd_sc_hd__decap_3
XFILLER_67_646 VGND VGND VPWR VPWR sky130_fd_sc_hd__decap_3
XFILLER_94_421 VGND VGND VPWR VPWR sky130_fd_sc_hd__decap_3
XFILLER_66_156 VGND VGND VPWR VPWR sky130_fd_sc_hd__decap_3
XFILLER_81_104 VGND VGND VPWR VPWR sky130_fd_sc_hd__decap_3
XFILLER_82_627 VGND VGND VPWR VPWR sky130_fd_sc_hd__fill_1
XFILLER_54_329 VGND VGND VPWR VPWR sky130_fd_sc_hd__decap_3
XFILLER_75_690 VGND VGND VPWR VPWR sky130_fd_sc_hd__fill_2
XFILLER_82_638 VGND VGND VPWR VPWR sky130_fd_sc_hd__fill_1
X_6920_ _6967_/CLK _6920_/D VGND VGND VPWR VPWR _6920_/Q sky130_fd_sc_hd__dfxtp_2
X_6851_ _6929_/CLK _6851_/D VGND VGND VPWR VPWR _6851_/Q sky130_fd_sc_hd__dfxtp_2
XFILLER_22_215 VGND VGND VPWR VPWR sky130_fd_sc_hd__decap_3
Xfanout19 _6536_/A VGND VGND VPWR VPWR _6540_/A sky130_fd_sc_hd__buf_2
XFILLER_22_248 VGND VGND VPWR VPWR sky130_fd_sc_hd__decap_3
XFILLER_22_259 VGND VGND VPWR VPWR sky130_fd_sc_hd__decap_3
X_6782_ _7384_/CLK _6782_/D VGND VGND VPWR VPWR _6782_/Q sky130_fd_sc_hd__dfxtp_2
X_3994_ _3994_/A0 _3993_/X _3994_/S VGND VGND VPWR VPWR _7345_/D sky130_fd_sc_hd__mux2_2
XFILLER_13_29 VGND VGND VPWR VPWR sky130_fd_sc_hd__decap_3
X_5733_ _7372_/Q hold948/X _5737_/S VGND VGND VPWR VPWR _6716_/D sky130_fd_sc_hd__mux2_2
X_5664_ _5664_/A _5664_/B _5664_/C _5664_/D VGND VGND VPWR VPWR _5665_/D sky130_fd_sc_hd__and4_2
XTAP_TAPCELL_ROW_79_1204 VGND VPWR sky130_fd_sc_hd__tapvpwrvgnd_1
XFILLER_108_309 VGND VGND VPWR VPWR sky130_fd_sc_hd__decap_3
XFILLER_30_292 VGND VGND VPWR VPWR sky130_fd_sc_hd__decap_3
X_7403_ _7403_/CLK _7403_/D _6683_/Y VGND VGND VPWR VPWR _7403_/Q sky130_fd_sc_hd__dfrtp_2
X_5595_ _5595_/A _5595_/B VGND VGND VPWR VPWR _7030_/D sky130_fd_sc_hd__or2_2
X_4615_ _4612_/A _4612_/B _3610_/A VGND VGND VPWR VPWR _4615_/Y sky130_fd_sc_hd__a21oi_2
X_7334_ _7393_/CLK _7334_/D _6614_/Y VGND VGND VPWR VPWR _7334_/Q sky130_fd_sc_hd__dfrtp_2
X_4546_ _7307_/Q _4569_/B VGND VGND VPWR VPWR _7307_/D sky130_fd_sc_hd__and2_2
XFILLER_116_353 VGND VGND VPWR VPWR sky130_fd_sc_hd__decap_3
XFILLER_104_526 VGND VGND VPWR VPWR sky130_fd_sc_hd__decap_3
XFILLER_89_237 VGND VGND VPWR VPWR sky130_fd_sc_hd__decap_3
X_7265_ _7363_/CLK _7265_/D _6545_/Y VGND VGND VPWR VPWR _7265_/Q sky130_fd_sc_hd__dfrtp_2
X_7196_ _7394_/CLK _7196_/D _6476_/Y VGND VGND VPWR VPWR _7196_/Q sky130_fd_sc_hd__dfrtp_2
XFILLER_38_15 VGND VGND VPWR VPWR sky130_fd_sc_hd__decap_3
XFILLER_38_26 VGND VGND VPWR VPWR sky130_fd_sc_hd__fill_2
Xhold1100 _7230_/Q VGND VGND VPWR VPWR _5196_/A sky130_fd_sc_hd__dlygate4sd3_1
X_3359_ _3561_/B _5130_/A VGND VGND VPWR VPWR _3376_/A sky130_fd_sc_hd__or2_2
XFILLER_112_581 VGND VGND VPWR VPWR sky130_fd_sc_hd__decap_3
XFILLER_112_592 VGND VGND VPWR VPWR sky130_fd_sc_hd__decap_3
XFILLER_57_134 VGND VGND VPWR VPWR sky130_fd_sc_hd__decap_3
XFILLER_85_432 VGND VGND VPWR VPWR sky130_fd_sc_hd__decap_3
XFILLER_97_281 VGND VGND VPWR VPWR sky130_fd_sc_hd__decap_3
Xhold1111 _7250_/Q VGND VGND VPWR VPWR _5140_/A0 sky130_fd_sc_hd__dlygate4sd3_1
Xhold1122 _7177_/Q VGND VGND VPWR VPWR _5306_/A0 sky130_fd_sc_hd__dlygate4sd3_1
Xhold1133 _7189_/Q VGND VGND VPWR VPWR _5282_/A1 sky130_fd_sc_hd__dlygate4sd3_1
XFILLER_57_156 VGND VGND VPWR VPWR sky130_fd_sc_hd__decap_3
Xhold1144 _7340_/Q VGND VGND VPWR VPWR _4478_/A0 sky130_fd_sc_hd__dlygate4sd3_1
Xhold1155 _7295_/Q VGND VGND VPWR VPWR _4571_/A sky130_fd_sc_hd__dlygate4sd3_1
Xhold1166 _7161_/Q VGND VGND VPWR VPWR _5340_/A0 sky130_fd_sc_hd__dlygate4sd3_1
XFILLER_57_189 VGND VGND VPWR VPWR sky130_fd_sc_hd__decap_3
XFILLER_72_137 VGND VGND VPWR VPWR sky130_fd_sc_hd__decap_3
XFILLER_85_498 VGND VGND VPWR VPWR sky130_fd_sc_hd__decap_3
Xhold1177 _7225_/Q VGND VGND VPWR VPWR _5207_/A sky130_fd_sc_hd__dlygate4sd3_1
Xhold1188 _7296_/Q VGND VGND VPWR VPWR _4569_/A sky130_fd_sc_hd__dlygate4sd3_1
Xhold1199 _7171_/Q VGND VGND VPWR VPWR _5319_/A0 sky130_fd_sc_hd__dlygate4sd3_1
XFILLER_53_340 VGND VGND VPWR VPWR sky130_fd_sc_hd__decap_3
XFILLER_54_47 VGND VGND VPWR VPWR sky130_fd_sc_hd__decap_3
XFILLER_81_660 VGND VGND VPWR VPWR sky130_fd_sc_hd__decap_3
XFILLER_53_373 VGND VGND VPWR VPWR sky130_fd_sc_hd__decap_3
XFILLER_81_682 VGND VGND VPWR VPWR sky130_fd_sc_hd__decap_3
XFILLER_110_42 VGND VGND VPWR VPWR sky130_fd_sc_hd__fill_2
XFILLER_13_237 VGND VGND VPWR VPWR sky130_fd_sc_hd__decap_3
XFILLER_41_535 VGND VGND VPWR VPWR sky130_fd_sc_hd__decap_3
XFILLER_110_64 VGND VGND VPWR VPWR sky130_fd_sc_hd__decap_3
XFILLER_13_259 VGND VGND VPWR VPWR sky130_fd_sc_hd__decap_3
XFILLER_70_24 VGND VGND VPWR VPWR sky130_fd_sc_hd__decap_3
XFILLER_70_35 VGND VGND VPWR VPWR sky130_fd_sc_hd__decap_3
XFILLER_9_208 VGND VGND VPWR VPWR sky130_fd_sc_hd__decap_3
XFILLER_21_270 VGND VGND VPWR VPWR sky130_fd_sc_hd__decap_3
XFILLER_21_281 VGND VGND VPWR VPWR sky130_fd_sc_hd__decap_3
XFILLER_70_57 VGND VGND VPWR VPWR sky130_fd_sc_hd__decap_3
XFILLER_5_414 VGND VGND VPWR VPWR sky130_fd_sc_hd__decap_3
XFILLER_79_11 VGND VGND VPWR VPWR sky130_fd_sc_hd__decap_3
XFILLER_79_66 VGND VGND VPWR VPWR sky130_fd_sc_hd__fill_1
XFILLER_0_141 VGND VGND VPWR VPWR sky130_fd_sc_hd__decap_3
XFILLER_110_518 VGND VGND VPWR VPWR sky130_fd_sc_hd__decap_3
XFILLER_110_529 VGND VGND VPWR VPWR sky130_fd_sc_hd__decap_3
XFILLER_95_21 VGND VGND VPWR VPWR sky130_fd_sc_hd__decap_3
XFILLER_48_134 VGND VGND VPWR VPWR sky130_fd_sc_hd__decap_3
XFILLER_76_421 VGND VGND VPWR VPWR sky130_fd_sc_hd__decap_3
XFILLER_36_318 VGND VGND VPWR VPWR sky130_fd_sc_hd__decap_3
XFILLER_49_668 VGND VGND VPWR VPWR sky130_fd_sc_hd__decap_3
XFILLER_64_605 VGND VGND VPWR VPWR sky130_fd_sc_hd__fill_1
XFILLER_64_616 VGND VGND VPWR VPWR sky130_fd_sc_hd__decap_3
XFILLER_91_402 VGND VGND VPWR VPWR sky130_fd_sc_hd__decap_3
XFILLER_95_98 VGND VGND VPWR VPWR sky130_fd_sc_hd__decap_3
XTAP_TAPCELL_ROW_47_814 VGND VPWR sky130_fd_sc_hd__tapvpwrvgnd_1
XFILLER_28_81 VGND VGND VPWR VPWR sky130_fd_sc_hd__decap_3
XFILLER_48_189 VGND VGND VPWR VPWR sky130_fd_sc_hd__decap_3
XFILLER_63_104 VGND VGND VPWR VPWR sky130_fd_sc_hd__decap_3
XFILLER_76_498 VGND VGND VPWR VPWR sky130_fd_sc_hd__decap_3
XFILLER_91_446 VGND VGND VPWR VPWR sky130_fd_sc_hd__fill_2
XFILLER_44_362 VGND VGND VPWR VPWR sky130_fd_sc_hd__fill_2
XTAP_TAPCELL_ROW_63_1005 VGND VPWR sky130_fd_sc_hd__tapvpwrvgnd_1
XTAP_TAPCELL_ROW_27_571 VGND VPWR sky130_fd_sc_hd__tapvpwrvgnd_1
XFILLER_71_181 VGND VGND VPWR VPWR sky130_fd_sc_hd__decap_3
XFILLER_81_6 VGND VGND VPWR VPWR sky130_fd_sc_hd__decap_3
XFILLER_12_292 VGND VGND VPWR VPWR sky130_fd_sc_hd__decap_3
XFILLER_8_241 VGND VGND VPWR VPWR sky130_fd_sc_hd__decap_3
X_4400_ _7178_/Q _4430_/B1 _5229_/C _7146_/Q _4399_/X VGND VGND VPWR VPWR _4400_/X
+ sky130_fd_sc_hd__a221o_2
XFILLER_5_30 VGND VGND VPWR VPWR sky130_fd_sc_hd__decap_3
Xoutput527 _6989_/Q VGND VGND VPWR VPWR pc_out[12] sky130_fd_sc_hd__clkdlybuf4s25_1
Xoutput516 _7412_/X VGND VGND VPWR VPWR instruction_out[30] sky130_fd_sc_hd__clkdlybuf4s25_1
Xoutput505 _5161_/A VGND VGND VPWR VPWR instruction_out[18] sky130_fd_sc_hd__clkdlybuf4s25_1
XFILLER_113_323 VGND VGND VPWR VPWR sky130_fd_sc_hd__decap_3
Xoutput549 _6980_/Q VGND VGND VPWR VPWR pc_out[3] sky130_fd_sc_hd__clkdlybuf4s25_1
Xoutput538 _6999_/Q VGND VGND VPWR VPWR pc_out[22] sky130_fd_sc_hd__clkdlybuf4s25_1
X_4331_ _7223_/Q _3318_/B _4534_/S _7036_/Q VGND VGND VPWR VPWR _4331_/X sky130_fd_sc_hd__a22o_2
XTAP_TAPCELL_ROW_74_1145 VGND VPWR sky130_fd_sc_hd__tapvpwrvgnd_1
XTAP_TAPCELL_ROW_74_1134 VGND VPWR sky130_fd_sc_hd__tapvpwrvgnd_1
XFILLER_99_535 VGND VGND VPWR VPWR sky130_fd_sc_hd__decap_3
X_7050_ _7401_/CLK _7050_/D _6330_/Y VGND VGND VPWR VPWR _7050_/Q sky130_fd_sc_hd__dfrtp_2
X_4262_ _7230_/Q _4262_/A2 _4507_/S _7294_/Q VGND VGND VPWR VPWR _4262_/X sky130_fd_sc_hd__a22o_2
XFILLER_101_529 VGND VGND VPWR VPWR sky130_fd_sc_hd__decap_3
XFILLER_113_367 VGND VGND VPWR VPWR sky130_fd_sc_hd__decap_3
XFILLER_86_218 VGND VGND VPWR VPWR sky130_fd_sc_hd__decap_3
XFILLER_39_134 VGND VGND VPWR VPWR sky130_fd_sc_hd__decap_3
XFILLER_79_281 VGND VGND VPWR VPWR sky130_fd_sc_hd__decap_3
X_4193_ _7359_/Q _4394_/B _4218_/A2 _7103_/Q VGND VGND VPWR VPWR _4193_/X sky130_fd_sc_hd__a22o_2
XFILLER_39_167 VGND VGND VPWR VPWR sky130_fd_sc_hd__fill_1
XFILLER_55_605 VGND VGND VPWR VPWR sky130_fd_sc_hd__decap_3
XFILLER_67_454 VGND VGND VPWR VPWR sky130_fd_sc_hd__fill_2
XFILLER_94_262 VGND VGND VPWR VPWR sky130_fd_sc_hd__decap_3
XFILLER_54_115 VGND VGND VPWR VPWR sky130_fd_sc_hd__fill_1
XFILLER_67_487 VGND VGND VPWR VPWR sky130_fd_sc_hd__decap_3
XFILLER_82_424 VGND VGND VPWR VPWR sky130_fd_sc_hd__decap_3
XFILLER_35_340 VGND VGND VPWR VPWR sky130_fd_sc_hd__decap_3
XFILLER_54_159 VGND VGND VPWR VPWR sky130_fd_sc_hd__fill_2
XFILLER_70_619 VGND VGND VPWR VPWR sky130_fd_sc_hd__decap_3
XFILLER_82_457 VGND VGND VPWR VPWR sky130_fd_sc_hd__decap_3
X_6903_ _6929_/CLK _6903_/D VGND VGND VPWR VPWR _6903_/Q sky130_fd_sc_hd__dfxtp_2
XTAP_TAPCELL_ROW_85_1274 VGND VPWR sky130_fd_sc_hd__tapvpwrvgnd_1
XFILLER_24_17 VGND VGND VPWR VPWR sky130_fd_sc_hd__decap_3
XFILLER_62_181 VGND VGND VPWR VPWR sky130_fd_sc_hd__fill_2
X_6834_ _6929_/CLK _6834_/D VGND VGND VPWR VPWR _6834_/Q sky130_fd_sc_hd__dfxtp_2
XFILLER_50_354 VGND VGND VPWR VPWR sky130_fd_sc_hd__decap_3
XFILLER_50_365 VGND VGND VPWR VPWR sky130_fd_sc_hd__decap_3
X_6765_ _6967_/CLK _6765_/D VGND VGND VPWR VPWR _6765_/Q sky130_fd_sc_hd__dfxtp_2
X_3977_ _7352_/Q _7320_/Q _3977_/S VGND VGND VPWR VPWR _7352_/D sky130_fd_sc_hd__mux2_2
XFILLER_50_387 VGND VGND VPWR VPWR sky130_fd_sc_hd__decap_3
XFILLER_108_106 VGND VGND VPWR VPWR sky130_fd_sc_hd__decap_3
XFILLER_40_27 VGND VGND VPWR VPWR sky130_fd_sc_hd__fill_1
X_6696_ _7351_/CLK _6696_/D VGND VGND VPWR VPWR _6696_/Q sky130_fd_sc_hd__dfxtp_2
XFILLER_40_38 VGND VGND VPWR VPWR sky130_fd_sc_hd__decap_3
X_5647_ _5647_/A _5647_/B VGND VGND VPWR VPWR _5647_/Y sky130_fd_sc_hd__nand2_2
XFILLER_116_172 VGND VGND VPWR VPWR sky130_fd_sc_hd__decap_3
X_7317_ clkload1/A _7317_/D _6597_/Y VGND VGND VPWR VPWR _7317_/Q sky130_fd_sc_hd__dfrtp_2
XFILLER_104_345 VGND VGND VPWR VPWR sky130_fd_sc_hd__decap_3
X_7248_ clkload7/A _7248_/D _6528_/Y VGND VGND VPWR VPWR _7248_/Q sky130_fd_sc_hd__dfrtp_2
XFILLER_49_69 VGND VGND VPWR VPWR sky130_fd_sc_hd__decap_3
XFILLER_77_218 VGND VGND VPWR VPWR sky130_fd_sc_hd__decap_3
X_7179_ _7340_/CLK _7179_/D _6459_/Y VGND VGND VPWR VPWR _7179_/Q sky130_fd_sc_hd__dfrtp_2
XFILLER_105_53 VGND VGND VPWR VPWR sky130_fd_sc_hd__decap_3
XFILLER_105_75 VGND VGND VPWR VPWR sky130_fd_sc_hd__decap_3
XFILLER_58_454 VGND VGND VPWR VPWR sky130_fd_sc_hd__decap_3
XFILLER_85_240 VGND VGND VPWR VPWR sky130_fd_sc_hd__decap_3
XFILLER_18_318 VGND VGND VPWR VPWR sky130_fd_sc_hd__decap_3
XFILLER_39_690 VGND VGND VPWR VPWR sky130_fd_sc_hd__fill_2
XFILLER_65_35 VGND VGND VPWR VPWR sky130_fd_sc_hd__decap_3
XFILLER_73_413 VGND VGND VPWR VPWR sky130_fd_sc_hd__decap_3
XFILLER_85_284 VGND VGND VPWR VPWR sky130_fd_sc_hd__decap_3
XFILLER_45_137 VGND VGND VPWR VPWR sky130_fd_sc_hd__decap_3
XFILLER_73_457 VGND VGND VPWR VPWR sky130_fd_sc_hd__decap_3
XFILLER_26_395 VGND VGND VPWR VPWR sky130_fd_sc_hd__decap_3
XFILLER_41_332 VGND VGND VPWR VPWR sky130_fd_sc_hd__decap_3
XFILLER_53_192 VGND VGND VPWR VPWR sky130_fd_sc_hd__decap_3
XFILLER_41_354 VGND VGND VPWR VPWR sky130_fd_sc_hd__decap_3
XFILLER_81_78 VGND VGND VPWR VPWR sky130_fd_sc_hd__decap_3
XTAP_TAPCELL_ROW_52_872 VGND VPWR sky130_fd_sc_hd__tapvpwrvgnd_1
XTAP_TAPCELL_ROW_24_541 VGND VPWR sky130_fd_sc_hd__tapvpwrvgnd_1
XFILLER_14_83 VGND VGND VPWR VPWR sky130_fd_sc_hd__fill_1
XFILLER_14_94 VGND VGND VPWR VPWR sky130_fd_sc_hd__decap_3
XFILLER_5_211 VGND VGND VPWR VPWR sky130_fd_sc_hd__decap_3
XFILLER_108_640 VGND VGND VPWR VPWR sky130_fd_sc_hd__decap_3
XFILLER_5_233 VGND VGND VPWR VPWR sky130_fd_sc_hd__decap_3
XFILLER_107_150 VGND VGND VPWR VPWR sky130_fd_sc_hd__decap_3
XFILLER_5_277 VGND VGND VPWR VPWR sky130_fd_sc_hd__decap_3
XFILLER_5_299 VGND VGND VPWR VPWR sky130_fd_sc_hd__decap_3
XFILLER_110_315 VGND VGND VPWR VPWR sky130_fd_sc_hd__fill_1
XFILLER_1_461 VGND VGND VPWR VPWR sky130_fd_sc_hd__decap_3
XFILLER_68_218 VGND VGND VPWR VPWR sky130_fd_sc_hd__decap_3
XFILLER_96_516 VGND VGND VPWR VPWR sky130_fd_sc_hd__decap_3
XFILLER_110_337 VGND VGND VPWR VPWR sky130_fd_sc_hd__decap_3
XFILLER_49_410 VGND VGND VPWR VPWR sky130_fd_sc_hd__decap_3
XFILLER_89_590 VGND VGND VPWR VPWR sky130_fd_sc_hd__fill_1
XFILLER_49_487 VGND VGND VPWR VPWR sky130_fd_sc_hd__fill_1
XFILLER_64_435 VGND VGND VPWR VPWR sky130_fd_sc_hd__decap_3
XFILLER_76_273 VGND VGND VPWR VPWR sky130_fd_sc_hd__decap_3
XFILLER_91_210 VGND VGND VPWR VPWR sky130_fd_sc_hd__decap_3
XFILLER_17_340 VGND VGND VPWR VPWR sky130_fd_sc_hd__fill_2
XFILLER_64_468 VGND VGND VPWR VPWR sky130_fd_sc_hd__decap_3
XFILLER_17_351 VGND VGND VPWR VPWR sky130_fd_sc_hd__fill_2
XFILLER_17_373 VGND VGND VPWR VPWR sky130_fd_sc_hd__fill_1
XFILLER_51_107 VGND VGND VPWR VPWR sky130_fd_sc_hd__fill_1
XFILLER_91_276 VGND VGND VPWR VPWR sky130_fd_sc_hd__fill_1
XFILLER_44_181 VGND VGND VPWR VPWR sky130_fd_sc_hd__decap_3
X_3900_ _3898_/X _3899_/X _5138_/S VGND VGND VPWR VPWR _3900_/Y sky130_fd_sc_hd__o21ai_2
X_3831_ _3682_/A _3828_/X _3830_/X _3714_/X VGND VGND VPWR VPWR _3831_/X sky130_fd_sc_hd__a22o_2
X_6550_ _6584_/A VGND VGND VPWR VPWR _6550_/Y sky130_fd_sc_hd__inv_2
X_3762_ _3746_/C _3759_/X _3760_/X _3818_/A2 VGND VGND VPWR VPWR _3762_/X sky130_fd_sc_hd__o31a_2
XFILLER_9_561 VGND VGND VPWR VPWR sky130_fd_sc_hd__fill_2
X_6481_ _6611_/A VGND VGND VPWR VPWR _6481_/Y sky130_fd_sc_hd__inv_2
X_3693_ _3693_/A0 _3692_/X _4832_/A VGND VGND VPWR VPWR _7403_/D sky130_fd_sc_hd__mux2_2
XFILLER_10_19 VGND VGND VPWR VPWR sky130_fd_sc_hd__decap_3
XFILLER_105_109 VGND VGND VPWR VPWR sky130_fd_sc_hd__decap_3
XFILLER_114_632 VGND VGND VPWR VPWR sky130_fd_sc_hd__decap_3
X_7102_ clkload6/A _7102_/D _6382_/Y VGND VGND VPWR VPWR _7102_/Q sky130_fd_sc_hd__dfrtp_2
X_4314_ _4376_/A _4364_/A _4364_/B _4313_/D VGND VGND VPWR VPWR _4315_/B sky130_fd_sc_hd__o31ai_2
XFILLER_99_343 VGND VGND VPWR VPWR sky130_fd_sc_hd__fill_1
XFILLER_99_332 VGND VGND VPWR VPWR sky130_fd_sc_hd__decap_3
XFILLER_113_142 VGND VGND VPWR VPWR sky130_fd_sc_hd__decap_3
XFILLER_113_164 VGND VGND VPWR VPWR sky130_fd_sc_hd__decap_3
XFILLER_59_218 VGND VGND VPWR VPWR sky130_fd_sc_hd__decap_3
XFILLER_87_505 VGND VGND VPWR VPWR sky130_fd_sc_hd__decap_3
X_5294_ _5294_/A _5294_/B VGND VGND VPWR VPWR _7412_/A sky130_fd_sc_hd__nor2_2
XFILLER_99_376 VGND VGND VPWR VPWR sky130_fd_sc_hd__decap_3
XFILLER_101_337 VGND VGND VPWR VPWR sky130_fd_sc_hd__decap_3
XFILLER_113_175 VGND VGND VPWR VPWR sky130_fd_sc_hd__decap_3
XFILLER_19_17 VGND VGND VPWR VPWR sky130_fd_sc_hd__decap_3
XFILLER_87_538 VGND VGND VPWR VPWR sky130_fd_sc_hd__fill_1
X_7033_ clkload3/A _7033_/D _6313_/Y VGND VGND VPWR VPWR _7033_/Q sky130_fd_sc_hd__dfrtp_2
X_4245_ _7357_/Q _4354_/B1 _4348_/A2 _7165_/Q _4244_/X VGND VGND VPWR VPWR _4248_/B
+ sky130_fd_sc_hd__a221o_2
XFILLER_67_240 VGND VGND VPWR VPWR sky130_fd_sc_hd__decap_3
X_4176_ _7168_/Q _4348_/A2 _3378_/Y _7136_/Q VGND VGND VPWR VPWR _4176_/X sky130_fd_sc_hd__a22o_2
XFILLER_55_424 VGND VGND VPWR VPWR sky130_fd_sc_hd__decap_3
XFILLER_67_284 VGND VGND VPWR VPWR sky130_fd_sc_hd__decap_3
XFILLER_27_137 VGND VGND VPWR VPWR sky130_fd_sc_hd__decap_3
XFILLER_35_27 VGND VGND VPWR VPWR sky130_fd_sc_hd__decap_3
XFILLER_42_118 VGND VGND VPWR VPWR sky130_fd_sc_hd__decap_3
XFILLER_55_479 VGND VGND VPWR VPWR sky130_fd_sc_hd__fill_2
XFILLER_70_427 VGND VGND VPWR VPWR sky130_fd_sc_hd__fill_1
XFILLER_82_265 VGND VGND VPWR VPWR sky130_fd_sc_hd__fill_1
XFILLER_23_310 VGND VGND VPWR VPWR sky130_fd_sc_hd__fill_2
XFILLER_35_192 VGND VGND VPWR VPWR sky130_fd_sc_hd__decap_3
XFILLER_70_438 VGND VGND VPWR VPWR sky130_fd_sc_hd__decap_3
X_6817_ _6967_/CLK _6817_/D VGND VGND VPWR VPWR _6817_/Q sky130_fd_sc_hd__dfxtp_2
XFILLER_50_162 VGND VGND VPWR VPWR sky130_fd_sc_hd__decap_3
XFILLER_51_15 VGND VGND VPWR VPWR sky130_fd_sc_hd__decap_3
XTAP_TAPCELL_ROW_21_500 VGND VPWR sky130_fd_sc_hd__tapvpwrvgnd_1
XFILLER_50_195 VGND VGND VPWR VPWR sky130_fd_sc_hd__fill_1
X_6748_ _6972_/CLK _6748_/D VGND VGND VPWR VPWR _6748_/Q sky130_fd_sc_hd__dfxtp_2
XFILLER_109_437 VGND VGND VPWR VPWR sky130_fd_sc_hd__decap_3
X_6679_ _6682_/A VGND VGND VPWR VPWR _6679_/Y sky130_fd_sc_hd__inv_2
XTAP_TAPCELL_ROW_98_1432 VGND VPWR sky130_fd_sc_hd__tapvpwrvgnd_1
XFILLER_104_164 VGND VGND VPWR VPWR sky130_fd_sc_hd__decap_3
XFILLER_116_41 VGND VGND VPWR VPWR sky130_fd_sc_hd__decap_3
XFILLER_104_197 VGND VGND VPWR VPWR sky130_fd_sc_hd__decap_3
XFILLER_116_52 VGND VGND VPWR VPWR sky130_fd_sc_hd__decap_3
XFILLER_116_74 VGND VGND VPWR VPWR sky130_fd_sc_hd__decap_3
XFILLER_116_85 VGND VGND VPWR VPWR sky130_fd_sc_hd__fill_1
XFILLER_76_23 VGND VGND VPWR VPWR sky130_fd_sc_hd__decap_3
XFILLER_58_251 VGND VGND VPWR VPWR sky130_fd_sc_hd__fill_1
XFILLER_76_56 VGND VGND VPWR VPWR sky130_fd_sc_hd__decap_3
XFILLER_93_508 VGND VGND VPWR VPWR sky130_fd_sc_hd__decap_3
XFILLER_86_571 VGND VGND VPWR VPWR sky130_fd_sc_hd__decap_3
XFILLER_86_582 VGND VGND VPWR VPWR sky130_fd_sc_hd__decap_3
XTAP_TAPCELL_ROW_29_600 VGND VPWR sky130_fd_sc_hd__tapvpwrvgnd_1
XFILLER_100_392 VGND VGND VPWR VPWR sky130_fd_sc_hd__decap_3
XFILLER_18_126 VGND VGND VPWR VPWR sky130_fd_sc_hd__fill_2
XFILLER_73_221 VGND VGND VPWR VPWR sky130_fd_sc_hd__decap_3
XFILLER_73_243 VGND VGND VPWR VPWR sky130_fd_sc_hd__fill_2
XTAP_TAPCELL_ROW_57_931 VGND VPWR sky130_fd_sc_hd__tapvpwrvgnd_1
XFILLER_73_287 VGND VGND VPWR VPWR sky130_fd_sc_hd__fill_1
XFILLER_33_129 VGND VGND VPWR VPWR sky130_fd_sc_hd__decap_3
XFILLER_61_438 VGND VGND VPWR VPWR sky130_fd_sc_hd__fill_1
XFILLER_61_449 VGND VGND VPWR VPWR sky130_fd_sc_hd__decap_3
XFILLER_73_298 VGND VGND VPWR VPWR sky130_fd_sc_hd__decap_3
XFILLER_92_88 VGND VGND VPWR VPWR sky130_fd_sc_hd__decap_3
XFILLER_14_365 VGND VGND VPWR VPWR sky130_fd_sc_hd__decap_3
XFILLER_25_60 VGND VGND VPWR VPWR sky130_fd_sc_hd__decap_3
XFILLER_41_140 VGND VGND VPWR VPWR sky130_fd_sc_hd__decap_3
XFILLER_25_93 VGND VGND VPWR VPWR sky130_fd_sc_hd__decap_3
XFILLER_10_582 VGND VGND VPWR VPWR sky130_fd_sc_hd__decap_3
XFILLER_41_81 VGND VGND VPWR VPWR sky130_fd_sc_hd__decap_3
XFILLER_69_505 VGND VGND VPWR VPWR sky130_fd_sc_hd__decap_3
XTAP_TAPCELL_ROW_71_1104 VGND VPWR sky130_fd_sc_hd__tapvpwrvgnd_1
XFILLER_69_538 VGND VGND VPWR VPWR sky130_fd_sc_hd__decap_3
XFILLER_96_324 VGND VGND VPWR VPWR sky130_fd_sc_hd__decap_3
XFILLER_2_42 VGND VGND VPWR VPWR sky130_fd_sc_hd__decap_3
XFILLER_84_519 VGND VGND VPWR VPWR sky130_fd_sc_hd__decap_3
XFILLER_96_357 VGND VGND VPWR VPWR sky130_fd_sc_hd__decap_3
XFILLER_96_368 VGND VGND VPWR VPWR sky130_fd_sc_hd__decap_3
XPHY_EDGE_ROW_10_Right_10 VGND VGND VPWR VPWR sky130_fd_sc_hd__decap_3
XFILLER_2_64 VGND VGND VPWR VPWR sky130_fd_sc_hd__decap_3
XFILLER_49_262 VGND VGND VPWR VPWR sky130_fd_sc_hd__decap_3
XFILLER_77_571 VGND VGND VPWR VPWR sky130_fd_sc_hd__decap_3
XFILLER_37_435 VGND VGND VPWR VPWR sky130_fd_sc_hd__fill_2
XFILLER_64_243 VGND VGND VPWR VPWR sky130_fd_sc_hd__decap_3
XFILLER_24_107 VGND VGND VPWR VPWR sky130_fd_sc_hd__decap_3
XFILLER_37_479 VGND VGND VPWR VPWR sky130_fd_sc_hd__decap_3
XFILLER_52_405 VGND VGND VPWR VPWR sky130_fd_sc_hd__decap_3
XTAP_TAPCELL_ROW_69_1077 VGND VPWR sky130_fd_sc_hd__tapvpwrvgnd_1
XFILLER_17_181 VGND VGND VPWR VPWR sky130_fd_sc_hd__decap_3
XFILLER_18_682 VGND VGND VPWR VPWR sky130_fd_sc_hd__fill_2
XFILLER_52_427 VGND VGND VPWR VPWR sky130_fd_sc_hd__decap_3
Xclkbuf_leaf_44_clk clkbuf_3_0__f_clk/X VGND VGND VPWR VPWR clkload4/A sky130_fd_sc_hd__clkbuf_16
X_4932_ _5092_/C _4927_/X _4929_/Y _6996_/D _4997_/A1 VGND VGND VPWR VPWR _4932_/X
+ sky130_fd_sc_hd__a32o_2
XTAP_TAPCELL_ROW_82_1233 VGND VPWR sky130_fd_sc_hd__tapvpwrvgnd_1
XTAP_TAPCELL_ROW_35_669 VGND VPWR sky130_fd_sc_hd__tapvpwrvgnd_1
XANTENNA_14 _4765_/A VGND VGND VPWR VPWR sky130_fd_sc_hd__diode_2
XFILLER_20_324 VGND VGND VPWR VPWR sky130_fd_sc_hd__decap_3
XFILLER_60_460 VGND VGND VPWR VPWR sky130_fd_sc_hd__decap_3
X_6602_ _6664_/A VGND VGND VPWR VPWR _6602_/Y sky130_fd_sc_hd__inv_2
XANTENNA_25 _3580_/X VGND VGND VPWR VPWR sky130_fd_sc_hd__diode_2
XFILLER_20_357 VGND VGND VPWR VPWR sky130_fd_sc_hd__decap_3
X_3814_ _7391_/Q _4466_/A _3813_/Y VGND VGND VPWR VPWR _7391_/D sky130_fd_sc_hd__a21bo_2
XFILLER_20_368 VGND VGND VPWR VPWR sky130_fd_sc_hd__decap_3
XFILLER_21_18 VGND VGND VPWR VPWR sky130_fd_sc_hd__decap_3
X_6533_ _6568_/A VGND VGND VPWR VPWR _6533_/Y sky130_fd_sc_hd__inv_2
X_3745_ _6978_/Q _3889_/A2 _3892_/B1 _6723_/Q _3744_/X VGND VGND VPWR VPWR _3745_/X
+ sky130_fd_sc_hd__a221o_2
X_6464_ _6672_/A VGND VGND VPWR VPWR _6464_/Y sky130_fd_sc_hd__inv_2
X_5415_ _7126_/Q _5121_/X _5419_/S VGND VGND VPWR VPWR _7126_/D sky130_fd_sc_hd__mux2_2
X_3676_ _6716_/Q VGND VGND VPWR VPWR _3676_/Y sky130_fd_sc_hd__inv_2
X_6395_ _6523_/A VGND VGND VPWR VPWR _6395_/Y sky130_fd_sc_hd__inv_2
XFILLER_87_302 VGND VGND VPWR VPWR sky130_fd_sc_hd__decap_3
X_5346_ _7158_/Q _5121_/X _5350_/S VGND VGND VPWR VPWR _7158_/D sky130_fd_sc_hd__mux2_2
XTAP_TAPCELL_ROW_93_1373 VGND VPWR sky130_fd_sc_hd__tapvpwrvgnd_1
XTAP_TAPCELL_ROW_93_1362 VGND VPWR sky130_fd_sc_hd__tapvpwrvgnd_1
XTAP_TAPCELL_ROW_7_339 VGND VPWR sky130_fd_sc_hd__tapvpwrvgnd_1
XFILLER_102_635 VGND VGND VPWR VPWR sky130_fd_sc_hd__decap_3
XFILLER_87_335 VGND VGND VPWR VPWR sky130_fd_sc_hd__fill_1
XFILLER_75_519 VGND VGND VPWR VPWR sky130_fd_sc_hd__decap_3
XFILLER_87_346 VGND VGND VPWR VPWR sky130_fd_sc_hd__decap_3
XFILLER_87_379 VGND VGND VPWR VPWR sky130_fd_sc_hd__decap_3
X_7016_ clkload6/A _7016_/D _6296_/Y VGND VGND VPWR VPWR _7016_/Q sky130_fd_sc_hd__dfrtp_2
X_4228_ _7014_/Q _3358_/X _3399_/A _7195_/Q _4227_/X VGND VGND VPWR VPWR _4228_/X
+ sky130_fd_sc_hd__a221o_2
XFILLER_101_189 VGND VGND VPWR VPWR sky130_fd_sc_hd__decap_3
XFILLER_46_15 VGND VGND VPWR VPWR sky130_fd_sc_hd__decap_3
XFILLER_68_560 VGND VGND VPWR VPWR sky130_fd_sc_hd__decap_3
XFILLER_28_446 VGND VGND VPWR VPWR sky130_fd_sc_hd__decap_3
XFILLER_55_210 VGND VGND VPWR VPWR sky130_fd_sc_hd__decap_3
XFILLER_55_243 VGND VGND VPWR VPWR sky130_fd_sc_hd__decap_3
XFILLER_95_390 VGND VGND VPWR VPWR sky130_fd_sc_hd__fill_2
X_4159_ _7329_/Q _3958_/S _4196_/A2 _7361_/Q _4188_/C1 VGND VGND VPWR VPWR _4159_/X
+ sky130_fd_sc_hd__a221o_2
XPHY_EDGE_ROW_106_Right_106 VGND VGND VPWR VPWR sky130_fd_sc_hd__decap_3
XFILLER_55_276 VGND VGND VPWR VPWR sky130_fd_sc_hd__decap_3
XFILLER_83_585 VGND VGND VPWR VPWR sky130_fd_sc_hd__decap_3
XTAP_TAPCELL_ROW_54_901 VGND VPWR sky130_fd_sc_hd__tapvpwrvgnd_1
XFILLER_102_43 VGND VGND VPWR VPWR sky130_fd_sc_hd__decap_3
XFILLER_102_54 VGND VGND VPWR VPWR sky130_fd_sc_hd__decap_3
XFILLER_43_438 VGND VGND VPWR VPWR sky130_fd_sc_hd__decap_3
XFILLER_43_449 VGND VGND VPWR VPWR sky130_fd_sc_hd__fill_1
XFILLER_70_235 VGND VGND VPWR VPWR sky130_fd_sc_hd__decap_3
Xclkbuf_leaf_35_clk clkbuf_3_0__f_clk/X VGND VGND VPWR VPWR _7384_/CLK sky130_fd_sc_hd__clkbuf_16
XFILLER_11_302 VGND VGND VPWR VPWR sky130_fd_sc_hd__decap_3
XFILLER_62_58 VGND VGND VPWR VPWR sky130_fd_sc_hd__decap_3
XFILLER_11_324 VGND VGND VPWR VPWR sky130_fd_sc_hd__decap_3
XFILLER_11_346 VGND VGND VPWR VPWR sky130_fd_sc_hd__decap_3
XTAP_TAPCELL_ROW_102_1480 VGND VPWR sky130_fd_sc_hd__tapvpwrvgnd_1
XFILLER_109_212 VGND VGND VPWR VPWR sky130_fd_sc_hd__decap_3
XFILLER_11_379 VGND VGND VPWR VPWR sky130_fd_sc_hd__decap_3
XFILLER_7_317 VGND VGND VPWR VPWR sky130_fd_sc_hd__decap_3
XFILLER_109_267 VGND VGND VPWR VPWR sky130_fd_sc_hd__decap_3
XFILLER_11_84 VGND VGND VPWR VPWR sky130_fd_sc_hd__decap_3
XFILLER_87_33 VGND VGND VPWR VPWR sky130_fd_sc_hd__decap_3
XFILLER_105_473 VGND VGND VPWR VPWR sky130_fd_sc_hd__decap_3
XFILLER_105_495 VGND VGND VPWR VPWR sky130_fd_sc_hd__decap_3
XFILLER_78_324 VGND VGND VPWR VPWR sky130_fd_sc_hd__decap_3
XFILLER_87_55 VGND VGND VPWR VPWR sky130_fd_sc_hd__fill_1
XFILLER_66_519 VGND VGND VPWR VPWR sky130_fd_sc_hd__decap_3
XFILLER_78_368 VGND VGND VPWR VPWR sky130_fd_sc_hd__decap_3
XFILLER_19_402 VGND VGND VPWR VPWR sky130_fd_sc_hd__decap_3
XFILLER_93_316 VGND VGND VPWR VPWR sky130_fd_sc_hd__decap_3
XFILLER_19_435 VGND VGND VPWR VPWR sky130_fd_sc_hd__fill_2
XFILLER_46_221 VGND VGND VPWR VPWR sky130_fd_sc_hd__decap_3
XFILLER_59_593 VGND VGND VPWR VPWR sky130_fd_sc_hd__decap_3
XFILLER_93_349 VGND VGND VPWR VPWR sky130_fd_sc_hd__decap_3
XFILLER_46_276 VGND VGND VPWR VPWR sky130_fd_sc_hd__fill_1
XFILLER_61_202 VGND VGND VPWR VPWR sky130_fd_sc_hd__decap_3
XFILLER_74_563 VGND VGND VPWR VPWR sky130_fd_sc_hd__decap_3
XTAP_TAPCELL_ROW_105_1509 VGND VPWR sky130_fd_sc_hd__tapvpwrvgnd_1
XFILLER_46_298 VGND VGND VPWR VPWR sky130_fd_sc_hd__fill_1
XFILLER_61_268 VGND VGND VPWR VPWR sky130_fd_sc_hd__decap_3
Xclkbuf_leaf_26_clk clkbuf_3_3__f_clk/X VGND VGND VPWR VPWR _6965_/CLK sky130_fd_sc_hd__clkbuf_16
XFILLER_30_622 VGND VGND VPWR VPWR sky130_fd_sc_hd__decap_3
XTAP_TAPCELL_ROW_32_639 VGND VPWR sky130_fd_sc_hd__tapvpwrvgnd_1
XFILLER_52_80 VGND VGND VPWR VPWR sky130_fd_sc_hd__decap_3
XTAP_TAPCELL_ROW_12_396 VGND VPWR sky130_fd_sc_hd__tapvpwrvgnd_1
XFILLER_6_350 VGND VGND VPWR VPWR sky130_fd_sc_hd__decap_3
Xhold807 _6860_/Q VGND VGND VPWR VPWR _6860_/D sky130_fd_sc_hd__dlygate4sd3_1
Xhold818 _6763_/Q VGND VGND VPWR VPWR _6763_/D sky130_fd_sc_hd__dlygate4sd3_1
XTAP_TAPCELL_ROW_116_1649 VGND VPWR sky130_fd_sc_hd__tapvpwrvgnd_1
XTAP_TAPCELL_ROW_116_1638 VGND VPWR sky130_fd_sc_hd__tapvpwrvgnd_1
Xhold829 _6831_/Q VGND VGND VPWR VPWR _6831_/D sky130_fd_sc_hd__dlygate4sd3_1
Xmax_cap559 _4447_/A VGND VGND VPWR VPWR _4795_/A sky130_fd_sc_hd__buf_2
X_3461_ _7281_/Q _4522_/S _4339_/B1 _7153_/Q _3460_/X VGND VGND VPWR VPWR _3461_/X
+ sky130_fd_sc_hd__a221o_2
XFILLER_42_3 VGND VGND VPWR VPWR sky130_fd_sc_hd__decap_3
XFILLER_69_302 VGND VGND VPWR VPWR sky130_fd_sc_hd__fill_1
X_5200_ _5200_/A _5217_/B VGND VGND VPWR VPWR _7228_/D sky130_fd_sc_hd__and2_2
X_3392_ _3392_/A _3429_/B VGND VGND VPWR VPWR _3591_/A sky130_fd_sc_hd__nor2_2
XFILLER_96_121 VGND VGND VPWR VPWR sky130_fd_sc_hd__decap_3
X_5131_ _3992_/Y _5128_/Y wire573/X _5156_/S VGND VGND VPWR VPWR _5131_/X sky130_fd_sc_hd__o22a_2
XFILLER_97_644 VGND VGND VPWR VPWR sky130_fd_sc_hd__decap_3
XFILLER_111_432 VGND VGND VPWR VPWR sky130_fd_sc_hd__decap_3
XFILLER_57_508 VGND VGND VPWR VPWR sky130_fd_sc_hd__decap_3
XFILLER_96_165 VGND VGND VPWR VPWR sky130_fd_sc_hd__decap_3
XFILLER_97_688 VGND VGND VPWR VPWR sky130_fd_sc_hd__decap_3
XFILLER_37_221 VGND VGND VPWR VPWR sky130_fd_sc_hd__decap_3
XFILLER_77_390 VGND VGND VPWR VPWR sky130_fd_sc_hd__fill_2
XFILLER_84_338 VGND VGND VPWR VPWR sky130_fd_sc_hd__decap_3
XFILLER_37_243 VGND VGND VPWR VPWR sky130_fd_sc_hd__decap_3
XFILLER_16_18 VGND VGND VPWR VPWR sky130_fd_sc_hd__decap_3
XFILLER_16_29 VGND VGND VPWR VPWR sky130_fd_sc_hd__decap_3
XFILLER_25_449 VGND VGND VPWR VPWR sky130_fd_sc_hd__decap_3
XFILLER_65_596 VGND VGND VPWR VPWR sky130_fd_sc_hd__decap_3
XFILLER_80_522 VGND VGND VPWR VPWR sky130_fd_sc_hd__fill_1
XFILLER_80_533 VGND VGND VPWR VPWR sky130_fd_sc_hd__decap_3
XFILLER_92_371 VGND VGND VPWR VPWR sky130_fd_sc_hd__decap_3
XFILLER_40_408 VGND VGND VPWR VPWR sky130_fd_sc_hd__decap_3
XFILLER_52_268 VGND VGND VPWR VPWR sky130_fd_sc_hd__decap_3
Xclkbuf_leaf_17_clk clkbuf_3_6__f_clk/X VGND VGND VPWR VPWR _7368_/CLK sky130_fd_sc_hd__clkbuf_16
XFILLER_20_132 VGND VGND VPWR VPWR sky130_fd_sc_hd__decap_3
XFILLER_21_633 VGND VGND VPWR VPWR sky130_fd_sc_hd__decap_3
XFILLER_21_644 VGND VGND VPWR VPWR sky130_fd_sc_hd__fill_2
X_4846_ _4903_/A _4890_/B VGND VGND VPWR VPWR _4884_/A sky130_fd_sc_hd__nand2_2
XFILLER_20_165 VGND VGND VPWR VPWR sky130_fd_sc_hd__decap_3
XFILLER_32_39 VGND VGND VPWR VPWR sky130_fd_sc_hd__decap_3
X_6516_ _6610_/A VGND VGND VPWR VPWR _6516_/Y sky130_fd_sc_hd__inv_2
X_4777_ _4983_/A _4777_/B _4777_/C VGND VGND VPWR VPWR _4777_/X sky130_fd_sc_hd__and3_2
XFILLER_106_215 VGND VGND VPWR VPWR sky130_fd_sc_hd__fill_2
XFILLER_4_309 VGND VGND VPWR VPWR sky130_fd_sc_hd__decap_3
X_3728_ _3746_/A _3728_/B VGND VGND VPWR VPWR _3728_/Y sky130_fd_sc_hd__nor2_2
XFILLER_106_237 VGND VGND VPWR VPWR sky130_fd_sc_hd__decap_3
X_6447_ _6610_/A VGND VGND VPWR VPWR _6447_/Y sky130_fd_sc_hd__inv_2
XFILLER_106_259 VGND VGND VPWR VPWR sky130_fd_sc_hd__decap_3
X_6378_ _6539_/A VGND VGND VPWR VPWR _6378_/Y sky130_fd_sc_hd__inv_2
XFILLER_102_421 VGND VGND VPWR VPWR sky130_fd_sc_hd__decap_3
XFILLER_114_270 VGND VGND VPWR VPWR sky130_fd_sc_hd__fill_2
X_5329_ _5329_/A0 _4997_/X _5340_/S VGND VGND VPWR VPWR _7166_/D sky130_fd_sc_hd__mux2_2
XFILLER_48_508 VGND VGND VPWR VPWR sky130_fd_sc_hd__decap_3
XFILLER_87_143 VGND VGND VPWR VPWR sky130_fd_sc_hd__decap_3
XFILLER_88_677 VGND VGND VPWR VPWR sky130_fd_sc_hd__fill_1
XFILLER_57_69 VGND VGND VPWR VPWR sky130_fd_sc_hd__decap_3
XFILLER_75_327 VGND VGND VPWR VPWR sky130_fd_sc_hd__decap_3
XFILLER_87_165 VGND VGND VPWR VPWR sky130_fd_sc_hd__decap_3
XFILLER_113_42 VGND VGND VPWR VPWR sky130_fd_sc_hd__decap_3
XFILLER_28_243 VGND VGND VPWR VPWR sky130_fd_sc_hd__decap_3
XFILLER_28_265 VGND VGND VPWR VPWR sky130_fd_sc_hd__decap_3
XFILLER_113_75 VGND VGND VPWR VPWR sky130_fd_sc_hd__decap_3
XFILLER_16_416 VGND VGND VPWR VPWR sky130_fd_sc_hd__decap_3
XFILLER_16_427 VGND VGND VPWR VPWR sky130_fd_sc_hd__decap_3
XFILLER_43_202 VGND VGND VPWR VPWR sky130_fd_sc_hd__decap_3
XFILLER_71_511 VGND VGND VPWR VPWR sky130_fd_sc_hd__decap_3
XFILLER_73_46 VGND VGND VPWR VPWR sky130_fd_sc_hd__decap_3
XFILLER_83_382 VGND VGND VPWR VPWR sky130_fd_sc_hd__decap_3
XFILLER_83_393 VGND VGND VPWR VPWR sky130_fd_sc_hd__decap_3
XFILLER_31_408 VGND VGND VPWR VPWR sky130_fd_sc_hd__fill_2
XFILLER_43_257 VGND VGND VPWR VPWR sky130_fd_sc_hd__decap_3
XFILLER_73_57 VGND VGND VPWR VPWR sky130_fd_sc_hd__decap_3
XFILLER_71_588 VGND VGND VPWR VPWR sky130_fd_sc_hd__decap_3
XFILLER_51_290 VGND VGND VPWR VPWR sky130_fd_sc_hd__decap_3
XFILLER_11_143 VGND VGND VPWR VPWR sky130_fd_sc_hd__decap_3
XFILLER_22_50 VGND VGND VPWR VPWR sky130_fd_sc_hd__decap_3
XFILLER_22_83 VGND VGND VPWR VPWR sky130_fd_sc_hd__fill_1
XFILLER_7_169 VGND VGND VPWR VPWR sky130_fd_sc_hd__decap_3
XFILLER_98_54 VGND VGND VPWR VPWR sky130_fd_sc_hd__decap_3
XFILLER_112_218 VGND VGND VPWR VPWR sky130_fd_sc_hd__fill_1
XFILLER_3_375 VGND VGND VPWR VPWR sky130_fd_sc_hd__decap_3
XFILLER_105_281 VGND VGND VPWR VPWR sky130_fd_sc_hd__decap_3
XFILLER_79_644 VGND VGND VPWR VPWR sky130_fd_sc_hd__decap_3
XFILLER_94_603 VGND VGND VPWR VPWR sky130_fd_sc_hd__decap_3
XTAP_TAPCELL_ROW_111_1579 VGND VPWR sky130_fd_sc_hd__tapvpwrvgnd_1
XFILLER_78_176 VGND VGND VPWR VPWR sky130_fd_sc_hd__decap_3
XFILLER_93_113 VGND VGND VPWR VPWR sky130_fd_sc_hd__decap_3
XFILLER_94_636 VGND VGND VPWR VPWR sky130_fd_sc_hd__decap_3
XFILLER_19_210 VGND VGND VPWR VPWR sky130_fd_sc_hd__decap_3
XFILLER_66_338 VGND VGND VPWR VPWR sky130_fd_sc_hd__decap_3
XFILLER_93_146 VGND VGND VPWR VPWR sky130_fd_sc_hd__decap_3
XFILLER_19_243 VGND VGND VPWR VPWR sky130_fd_sc_hd__decap_3
XFILLER_47_80 VGND VGND VPWR VPWR sky130_fd_sc_hd__decap_3
XFILLER_19_276 VGND VGND VPWR VPWR sky130_fd_sc_hd__decap_3
XFILLER_19_287 VGND VGND VPWR VPWR sky130_fd_sc_hd__decap_3
XFILLER_62_533 VGND VGND VPWR VPWR sky130_fd_sc_hd__decap_3
XTAP_TAPCELL_ROW_66_1047 VGND VPWR sky130_fd_sc_hd__tapvpwrvgnd_1
XTAP_TAPCELL_ROW_17_455 VGND VPWR sky130_fd_sc_hd__tapvpwrvgnd_1
XFILLER_22_419 VGND VGND VPWR VPWR sky130_fd_sc_hd__fill_1
XFILLER_34_268 VGND VGND VPWR VPWR sky130_fd_sc_hd__decap_3
XTAP_TAPCELL_ROW_45_797 VGND VPWR sky130_fd_sc_hd__tapvpwrvgnd_1
XTAP_TAPCELL_ROW_45_786 VGND VPWR sky130_fd_sc_hd__tapvpwrvgnd_1
XFILLER_30_430 VGND VGND VPWR VPWR sky130_fd_sc_hd__decap_3
X_5680_ _7346_/Q hold951/X _5706_/S VGND VGND VPWR VPWR _6690_/D sky130_fd_sc_hd__mux2_2
X_4700_ _6988_/Q _5066_/A VGND VGND VPWR VPWR _5044_/A sky130_fd_sc_hd__and2_2
XFILLER_30_463 VGND VGND VPWR VPWR sky130_fd_sc_hd__decap_3
X_4631_ _5003_/A _4620_/C _4630_/X _4273_/Y VGND VGND VPWR VPWR _4631_/X sky130_fd_sc_hd__a31o_2
XFILLER_8_52 VGND VGND VPWR VPWR sky130_fd_sc_hd__decap_3
XFILLER_8_74 VGND VGND VPWR VPWR sky130_fd_sc_hd__decap_3
XFILLER_8_85 VGND VGND VPWR VPWR sky130_fd_sc_hd__decap_3
XFILLER_116_502 VGND VGND VPWR VPWR sky130_fd_sc_hd__fill_2
XFILLER_116_513 VGND VGND VPWR VPWR sky130_fd_sc_hd__decap_3
X_7350_ _7351_/CLK _7350_/D _6630_/Y VGND VGND VPWR VPWR _7350_/Q sky130_fd_sc_hd__dfrtp_2
X_7281_ clkload8/A _7281_/D _6561_/Y VGND VGND VPWR VPWR _7281_/Q sky130_fd_sc_hd__dfrtp_2
Xhold604 _6787_/Q VGND VGND VPWR VPWR _6787_/D sky130_fd_sc_hd__dlygate4sd3_1
Xhold615 _6940_/Q VGND VGND VPWR VPWR _6940_/D sky130_fd_sc_hd__dlygate4sd3_1
Xhold626 _6805_/Q VGND VGND VPWR VPWR _6805_/D sky130_fd_sc_hd__dlygate4sd3_1
X_6301_ _6644_/A VGND VGND VPWR VPWR _6301_/Y sky130_fd_sc_hd__inv_2
X_4493_ _4493_/A0 _7301_/Q _4501_/S VGND VGND VPWR VPWR _7333_/D sky130_fd_sc_hd__mux2_2
XFILLER_116_557 VGND VGND VPWR VPWR sky130_fd_sc_hd__decap_3
XFILLER_89_408 VGND VGND VPWR VPWR sky130_fd_sc_hd__decap_3
Xclkbuf_leaf_6_clk clkbuf_leaf_7_clk/A VGND VGND VPWR VPWR _7363_/CLK sky130_fd_sc_hd__clkbuf_16
Xhold637 _6828_/Q VGND VGND VPWR VPWR _6828_/D sky130_fd_sc_hd__dlygate4sd3_1
Xhold648 _6735_/Q VGND VGND VPWR VPWR _6735_/D sky130_fd_sc_hd__dlygate4sd3_1
Xhold659 _6767_/Q VGND VGND VPWR VPWR _6767_/D sky130_fd_sc_hd__dlygate4sd3_1
XTAP_TAPCELL_ROW_77_1176 VGND VPWR sky130_fd_sc_hd__tapvpwrvgnd_1
XTAP_TAPCELL_ROW_90_1332 VGND VPWR sky130_fd_sc_hd__tapvpwrvgnd_1
XFILLER_69_143 VGND VGND VPWR VPWR sky130_fd_sc_hd__decap_3
XFILLER_97_452 VGND VGND VPWR VPWR sky130_fd_sc_hd__decap_3
X_3375_ _5118_/A _3399_/B VGND VGND VPWR VPWR _5641_/A sky130_fd_sc_hd__nand2_2
XFILLER_57_305 VGND VGND VPWR VPWR sky130_fd_sc_hd__decap_3
X_5114_ _5114_/A _5114_/B VGND VGND VPWR VPWR _5114_/Y sky130_fd_sc_hd__nand2_2
XFILLER_57_349 VGND VGND VPWR VPWR sky130_fd_sc_hd__decap_3
XFILLER_69_187 VGND VGND VPWR VPWR sky130_fd_sc_hd__decap_3
XFILLER_84_124 VGND VGND VPWR VPWR sky130_fd_sc_hd__decap_3
X_5045_ _6988_/Q _5045_/B VGND VGND VPWR VPWR _5045_/X sky130_fd_sc_hd__or2_2
XFILLER_27_28 VGND VGND VPWR VPWR sky130_fd_sc_hd__decap_3
XFILLER_25_202 VGND VGND VPWR VPWR sky130_fd_sc_hd__decap_3
XFILLER_65_393 VGND VGND VPWR VPWR sky130_fd_sc_hd__decap_3
XFILLER_93_691 VGND VGND VPWR VPWR sky130_fd_sc_hd__fill_1
XFILLER_25_257 VGND VGND VPWR VPWR sky130_fd_sc_hd__decap_3
X_6996_ _7403_/CLK _6996_/D _6276_/Y VGND VGND VPWR VPWR _6996_/Q sky130_fd_sc_hd__dfrtp_2
XFILLER_13_419 VGND VGND VPWR VPWR sky130_fd_sc_hd__decap_3
XFILLER_80_374 VGND VGND VPWR VPWR sky130_fd_sc_hd__fill_1
XFILLER_33_290 VGND VGND VPWR VPWR sky130_fd_sc_hd__fill_1
XFILLER_40_238 VGND VGND VPWR VPWR sky130_fd_sc_hd__decap_3
XFILLER_21_441 VGND VGND VPWR VPWR sky130_fd_sc_hd__decap_3
X_4829_ _4948_/A _4829_/B VGND VGND VPWR VPWR _4829_/Y sky130_fd_sc_hd__nor2_2
XFILLER_107_513 VGND VGND VPWR VPWR sky130_fd_sc_hd__decap_3
XFILLER_107_546 VGND VGND VPWR VPWR sky130_fd_sc_hd__decap_3
XFILLER_0_301 VGND VGND VPWR VPWR sky130_fd_sc_hd__decap_3
XFILLER_108_97 VGND VGND VPWR VPWR sky130_fd_sc_hd__decap_3
XFILLER_88_441 VGND VGND VPWR VPWR sky130_fd_sc_hd__decap_3
XFILLER_0_356 VGND VGND VPWR VPWR sky130_fd_sc_hd__fill_2
XFILLER_102_262 VGND VGND VPWR VPWR sky130_fd_sc_hd__decap_3
XFILLER_68_79 VGND VGND VPWR VPWR sky130_fd_sc_hd__decap_3
XFILLER_76_603 VGND VGND VPWR VPWR sky130_fd_sc_hd__decap_3
XFILLER_88_474 VGND VGND VPWR VPWR sky130_fd_sc_hd__fill_2
XFILLER_48_327 VGND VGND VPWR VPWR sky130_fd_sc_hd__decap_3
XFILLER_75_113 VGND VGND VPWR VPWR sky130_fd_sc_hd__decap_3
XFILLER_84_12 VGND VGND VPWR VPWR sky130_fd_sc_hd__decap_3
XFILLER_63_308 VGND VGND VPWR VPWR sky130_fd_sc_hd__decap_3
XFILLER_91_606 VGND VGND VPWR VPWR sky130_fd_sc_hd__decap_3
XFILLER_91_617 VGND VGND VPWR VPWR sky130_fd_sc_hd__decap_3
XFILLER_56_360 VGND VGND VPWR VPWR sky130_fd_sc_hd__decap_3
XFILLER_56_371 VGND VGND VPWR VPWR sky130_fd_sc_hd__decap_3
Xplace319 _3424_/S VGND VGND VPWR VPWR _4327_/A sky130_fd_sc_hd__buf_2
Xplace308 _3618_/X VGND VGND VPWR VPWR _4969_/B sky130_fd_sc_hd__buf_2
XFILLER_44_566 VGND VGND VPWR VPWR sky130_fd_sc_hd__fill_1
XFILLER_71_352 VGND VGND VPWR VPWR sky130_fd_sc_hd__decap_3
XFILLER_16_268 VGND VGND VPWR VPWR sky130_fd_sc_hd__decap_3
XFILLER_12_430 VGND VGND VPWR VPWR sky130_fd_sc_hd__fill_2
XFILLER_71_396 VGND VGND VPWR VPWR sky130_fd_sc_hd__decap_3
XTAP_TAPCELL_ROW_42_756 VGND VPWR sky130_fd_sc_hd__tapvpwrvgnd_1
XTAP_TAPCELL_ROW_14_425 VGND VPWR sky130_fd_sc_hd__tapvpwrvgnd_1
XTAP_TAPCELL_ROW_14_414 VGND VPWR sky130_fd_sc_hd__tapvpwrvgnd_1
XFILLER_12_463 VGND VGND VPWR VPWR sky130_fd_sc_hd__decap_3
XFILLER_33_60 VGND VGND VPWR VPWR sky130_fd_sc_hd__fill_2
XFILLER_8_401 VGND VGND VPWR VPWR sky130_fd_sc_hd__decap_3
XFILLER_33_82 VGND VGND VPWR VPWR sky130_fd_sc_hd__fill_1
XFILLER_33_93 VGND VGND VPWR VPWR sky130_fd_sc_hd__decap_3
XFILLER_76_9 VGND VGND VPWR VPWR sky130_fd_sc_hd__fill_1
XFILLER_113_505 VGND VGND VPWR VPWR sky130_fd_sc_hd__decap_3
XTAP_TAPCELL_ROW_113_1608 VGND VPWR sky130_fd_sc_hd__tapvpwrvgnd_1
XFILLER_79_441 VGND VGND VPWR VPWR sky130_fd_sc_hd__decap_3
XFILLER_79_452 VGND VGND VPWR VPWR sky130_fd_sc_hd__decap_3
XFILLER_39_305 VGND VGND VPWR VPWR sky130_fd_sc_hd__fill_2
XFILLER_67_603 VGND VGND VPWR VPWR sky130_fd_sc_hd__decap_3
XFILLER_79_485 VGND VGND VPWR VPWR sky130_fd_sc_hd__decap_3
XFILLER_94_433 VGND VGND VPWR VPWR sky130_fd_sc_hd__decap_3
XFILLER_66_168 VGND VGND VPWR VPWR sky130_fd_sc_hd__decap_3
XFILLER_47_371 VGND VGND VPWR VPWR sky130_fd_sc_hd__decap_3
XFILLER_47_393 VGND VGND VPWR VPWR sky130_fd_sc_hd__decap_3
XFILLER_62_341 VGND VGND VPWR VPWR sky130_fd_sc_hd__decap_3
X_6850_ _6909_/CLK _6850_/D VGND VGND VPWR VPWR _6850_/Q sky130_fd_sc_hd__dfxtp_2
X_6781_ _6929_/CLK _6781_/D VGND VGND VPWR VPWR _6781_/Q sky130_fd_sc_hd__dfxtp_2
XPHY_EDGE_ROW_8_Right_8 VGND VGND VPWR VPWR sky130_fd_sc_hd__decap_3
XFILLER_22_227 VGND VGND VPWR VPWR sky130_fd_sc_hd__decap_3
X_3993_ _4467_/B _3919_/X _3991_/X _3992_/Y VGND VGND VPWR VPWR _3993_/X sky130_fd_sc_hd__a31o_2
XFILLER_15_290 VGND VGND VPWR VPWR sky130_fd_sc_hd__decap_3
XFILLER_30_271 VGND VGND VPWR VPWR sky130_fd_sc_hd__decap_3
X_5663_ _5663_/A _5663_/B _5663_/C _5663_/D VGND VGND VPWR VPWR _5664_/D sky130_fd_sc_hd__nor4_2
XTAP_TAPCELL_ROW_79_1205 VGND VPWR sky130_fd_sc_hd__tapvpwrvgnd_1
X_7402_ _7406_/CLK _7402_/D _6682_/Y VGND VGND VPWR VPWR _7402_/Q sky130_fd_sc_hd__dfrtp_2
X_4614_ _4614_/A _4614_/B _4614_/C _5113_/A VGND VGND VPWR VPWR _4614_/X sky130_fd_sc_hd__and4_4
XFILLER_116_321 VGND VGND VPWR VPWR sky130_fd_sc_hd__decap_3
X_7333_ _7363_/CLK _7333_/D _6613_/Y VGND VGND VPWR VPWR _7333_/Q sky130_fd_sc_hd__dfrtp_2
XFILLER_116_365 VGND VGND VPWR VPWR sky130_fd_sc_hd__decap_3
XFILLER_104_538 VGND VGND VPWR VPWR sky130_fd_sc_hd__decap_3
X_7264_ _7359_/CLK _7264_/D _6544_/Y VGND VGND VPWR VPWR _7264_/Q sky130_fd_sc_hd__dfrtp_2
X_4476_ _4476_/A0 _4542_/A _4491_/S VGND VGND VPWR VPWR _7341_/D sky130_fd_sc_hd__mux2_2
XFILLER_89_249 VGND VGND VPWR VPWR sky130_fd_sc_hd__decap_3
X_7195_ _7360_/CLK _7195_/D _6475_/Y VGND VGND VPWR VPWR _7195_/Q sky130_fd_sc_hd__dfrtp_2
X_3427_ _3527_/A _3427_/B VGND VGND VPWR VPWR _3508_/A sky130_fd_sc_hd__nand2b_2
XPHY_EDGE_ROW_39_Right_39 VGND VGND VPWR VPWR sky130_fd_sc_hd__decap_3
XFILLER_85_411 VGND VGND VPWR VPWR sky130_fd_sc_hd__decap_3
X_3358_ _3469_/A _3469_/B _3449_/A _3365_/A VGND VGND VPWR VPWR _3358_/X sky130_fd_sc_hd__o211a_4
XFILLER_38_38 VGND VGND VPWR VPWR sky130_fd_sc_hd__decap_3
XFILLER_57_113 VGND VGND VPWR VPWR sky130_fd_sc_hd__decap_3
XFILLER_85_444 VGND VGND VPWR VPWR sky130_fd_sc_hd__decap_3
XFILLER_97_293 VGND VGND VPWR VPWR sky130_fd_sc_hd__decap_3
Xhold1101 _7332_/Q VGND VGND VPWR VPWR _4495_/A0 sky130_fd_sc_hd__dlygate4sd3_1
Xhold1112 _7138_/Q VGND VGND VPWR VPWR _5390_/A0 sky130_fd_sc_hd__dlygate4sd3_1
Xhold1123 _7301_/Q VGND VGND VPWR VPWR _4559_/A sky130_fd_sc_hd__dlygate4sd3_1
XFILLER_73_617 VGND VGND VPWR VPWR sky130_fd_sc_hd__decap_3
XFILLER_85_455 VGND VGND VPWR VPWR sky130_fd_sc_hd__decap_3
Xhold1134 _7305_/Q VGND VGND VPWR VPWR _4550_/A sky130_fd_sc_hd__dlygate4sd3_1
Xhold1145 _7220_/Q VGND VGND VPWR VPWR _5217_/A sky130_fd_sc_hd__dlygate4sd3_1
Xhold1156 _7195_/Q VGND VGND VPWR VPWR _5270_/A0 sky130_fd_sc_hd__dlygate4sd3_1
Xhold1167 _7152_/Q VGND VGND VPWR VPWR _5358_/A0 sky130_fd_sc_hd__dlygate4sd3_1
XFILLER_26_522 VGND VGND VPWR VPWR sky130_fd_sc_hd__fill_1
XFILLER_72_105 VGND VGND VPWR VPWR sky130_fd_sc_hd__decap_3
XFILLER_72_116 VGND VGND VPWR VPWR sky130_fd_sc_hd__decap_3
Xhold1178 _7137_/Q VGND VGND VPWR VPWR _5392_/A0 sky130_fd_sc_hd__dlygate4sd3_1
Xhold1189 _7156_/Q VGND VGND VPWR VPWR _5350_/A0 sky130_fd_sc_hd__dlygate4sd3_1
X_5028_ _5028_/A0 _5027_/X _5028_/S VGND VGND VPWR VPWR _7260_/D sky130_fd_sc_hd__mux2_2
XFILLER_54_15 VGND VGND VPWR VPWR sky130_fd_sc_hd__decap_3
XFILLER_54_26 VGND VGND VPWR VPWR sky130_fd_sc_hd__fill_2
XFILLER_65_190 VGND VGND VPWR VPWR sky130_fd_sc_hd__decap_3
XFILLER_41_514 VGND VGND VPWR VPWR sky130_fd_sc_hd__decap_3
XFILLER_53_352 VGND VGND VPWR VPWR sky130_fd_sc_hd__decap_3
XFILLER_54_59 VGND VGND VPWR VPWR sky130_fd_sc_hd__fill_2
XFILLER_80_160 VGND VGND VPWR VPWR sky130_fd_sc_hd__decap_3
XFILLER_80_193 VGND VGND VPWR VPWR sky130_fd_sc_hd__decap_3
X_6979_ _7364_/CLK _6979_/D _6259_/Y VGND VGND VPWR VPWR _6979_/Q sky130_fd_sc_hd__dfrtp_2
XPHY_EDGE_ROW_48_Right_48 VGND VGND VPWR VPWR sky130_fd_sc_hd__decap_3
XFILLER_110_76 VGND VGND VPWR VPWR sky130_fd_sc_hd__decap_3
XFILLER_41_569 VGND VGND VPWR VPWR sky130_fd_sc_hd__fill_1
XFILLER_21_293 VGND VGND VPWR VPWR sky130_fd_sc_hd__decap_3
XFILLER_107_310 VGND VGND VPWR VPWR sky130_fd_sc_hd__decap_3
XFILLER_5_426 VGND VGND VPWR VPWR sky130_fd_sc_hd__decap_3
XFILLER_107_343 VGND VGND VPWR VPWR sky130_fd_sc_hd__decap_3
XFILLER_79_45 VGND VGND VPWR VPWR sky130_fd_sc_hd__fill_2
XFILLER_107_376 VGND VGND VPWR VPWR sky130_fd_sc_hd__decap_3
XPHY_EDGE_ROW_57_Right_57 VGND VGND VPWR VPWR sky130_fd_sc_hd__decap_3
Xhold990 _6695_/Q VGND VGND VPWR VPWR hold990/X sky130_fd_sc_hd__dlygate4sd3_1
XFILLER_0_131 VGND VGND VPWR VPWR sky130_fd_sc_hd__decap_3
XFILLER_49_614 VGND VGND VPWR VPWR sky130_fd_sc_hd__fill_2
XFILLER_95_208 VGND VGND VPWR VPWR sky130_fd_sc_hd__decap_3
XFILLER_0_164 VGND VGND VPWR VPWR sky130_fd_sc_hd__decap_3
XFILLER_0_175 VGND VGND VPWR VPWR sky130_fd_sc_hd__decap_3
XFILLER_0_197 VGND VGND VPWR VPWR sky130_fd_sc_hd__decap_3
XFILLER_103_582 VGND VGND VPWR VPWR sky130_fd_sc_hd__decap_3
XFILLER_76_411 VGND VGND VPWR VPWR sky130_fd_sc_hd__decap_3
XFILLER_76_433 VGND VGND VPWR VPWR sky130_fd_sc_hd__decap_3
XFILLER_88_271 VGND VGND VPWR VPWR sky130_fd_sc_hd__fill_1
XFILLER_88_293 VGND VGND VPWR VPWR sky130_fd_sc_hd__fill_2
XFILLER_95_33 VGND VGND VPWR VPWR sky130_fd_sc_hd__decap_3
XFILLER_95_55 VGND VGND VPWR VPWR sky130_fd_sc_hd__fill_1
XFILLER_95_66 VGND VGND VPWR VPWR sky130_fd_sc_hd__decap_3
XFILLER_76_466 VGND VGND VPWR VPWR sky130_fd_sc_hd__decap_3
XFILLER_76_477 VGND VGND VPWR VPWR sky130_fd_sc_hd__decap_3
XFILLER_28_93 VGND VGND VPWR VPWR sky130_fd_sc_hd__decap_3
XTAP_TAPCELL_ROW_47_815 VGND VPWR sky130_fd_sc_hd__tapvpwrvgnd_1
XFILLER_29_393 VGND VGND VPWR VPWR sky130_fd_sc_hd__decap_3
XFILLER_44_330 VGND VGND VPWR VPWR sky130_fd_sc_hd__decap_3
XFILLER_91_458 VGND VGND VPWR VPWR sky130_fd_sc_hd__decap_3
XFILLER_44_374 VGND VGND VPWR VPWR sky130_fd_sc_hd__decap_3
XFILLER_71_160 VGND VGND VPWR VPWR sky130_fd_sc_hd__decap_3
XFILLER_72_661 VGND VGND VPWR VPWR sky130_fd_sc_hd__decap_3
XTAP_TAPCELL_ROW_63_1006 VGND VPWR sky130_fd_sc_hd__tapvpwrvgnd_1
XPHY_EDGE_ROW_66_Right_66 VGND VGND VPWR VPWR sky130_fd_sc_hd__decap_3
XFILLER_44_70 VGND VGND VPWR VPWR sky130_fd_sc_hd__decap_3
XFILLER_71_193 VGND VGND VPWR VPWR sky130_fd_sc_hd__decap_3
XTAP_TAPCELL_ROW_27_572 VGND VPWR sky130_fd_sc_hd__tapvpwrvgnd_1
XFILLER_12_271 VGND VGND VPWR VPWR sky130_fd_sc_hd__decap_3
XFILLER_8_220 VGND VGND VPWR VPWR sky130_fd_sc_hd__decap_3
XFILLER_8_253 VGND VGND VPWR VPWR sky130_fd_sc_hd__decap_3
Xoutput517 _5642_/A VGND VGND VPWR VPWR instruction_out[3] sky130_fd_sc_hd__clkdlybuf4s25_1
Xoutput506 _3421_/B VGND VGND VPWR VPWR instruction_out[20] sky130_fd_sc_hd__clkdlybuf4s25_1
XPHY_EDGE_ROW_75_Right_75 VGND VGND VPWR VPWR sky130_fd_sc_hd__decap_3
XFILLER_99_503 VGND VGND VPWR VPWR sky130_fd_sc_hd__fill_1
XFILLER_113_302 VGND VGND VPWR VPWR sky130_fd_sc_hd__decap_3
Xoutput539 _7000_/Q VGND VGND VPWR VPWR pc_out[23] sky130_fd_sc_hd__clkdlybuf4s25_1
Xoutput528 _6990_/Q VGND VGND VPWR VPWR pc_out[13] sky130_fd_sc_hd__clkdlybuf4s25_1
X_4330_ _5057_/B _4330_/B VGND VGND VPWR VPWR _4619_/B sky130_fd_sc_hd__or2_2
XTAP_TAPCELL_ROW_74_1135 VGND VPWR sky130_fd_sc_hd__tapvpwrvgnd_1
XFILLER_99_514 VGND VGND VPWR VPWR sky130_fd_sc_hd__decap_3
XFILLER_113_335 VGND VGND VPWR VPWR sky130_fd_sc_hd__fill_1
XFILLER_113_346 VGND VGND VPWR VPWR sky130_fd_sc_hd__decap_3
X_4261_ _7358_/Q _4354_/B1 _4348_/A2 _7166_/Q _4248_/A VGND VGND VPWR VPWR _4261_/X
+ sky130_fd_sc_hd__a221o_2
XFILLER_99_558 VGND VGND VPWR VPWR sky130_fd_sc_hd__fill_2
XFILLER_101_508 VGND VGND VPWR VPWR sky130_fd_sc_hd__decap_3
XFILLER_113_379 VGND VGND VPWR VPWR sky130_fd_sc_hd__decap_3
XFILLER_79_260 VGND VGND VPWR VPWR sky130_fd_sc_hd__decap_3
XFILLER_39_113 VGND VGND VPWR VPWR sky130_fd_sc_hd__decap_3
XFILLER_67_433 VGND VGND VPWR VPWR sky130_fd_sc_hd__decap_3
X_4192_ _4637_/B _4637_/C VGND VGND VPWR VPWR _4380_/A sky130_fd_sc_hd__and2_2
XFILLER_27_308 VGND VGND VPWR VPWR sky130_fd_sc_hd__fill_2
XFILLER_55_617 VGND VGND VPWR VPWR sky130_fd_sc_hd__decap_3
XFILLER_67_466 VGND VGND VPWR VPWR sky130_fd_sc_hd__decap_3
XFILLER_94_230 VGND VGND VPWR VPWR sky130_fd_sc_hd__decap_3
XFILLER_27_319 VGND VGND VPWR VPWR sky130_fd_sc_hd__decap_3
XFILLER_54_127 VGND VGND VPWR VPWR sky130_fd_sc_hd__fill_1
XFILLER_67_499 VGND VGND VPWR VPWR sky130_fd_sc_hd__decap_3
XFILLER_82_403 VGND VGND VPWR VPWR sky130_fd_sc_hd__decap_3
XFILLER_82_436 VGND VGND VPWR VPWR sky130_fd_sc_hd__decap_3
XFILLER_94_296 VGND VGND VPWR VPWR sky130_fd_sc_hd__decap_3
XPHY_EDGE_ROW_84_Right_84 VGND VGND VPWR VPWR sky130_fd_sc_hd__decap_3
XPHY_EDGE_ROW_19_Left_136 VGND VGND VPWR VPWR sky130_fd_sc_hd__decap_3
XFILLER_47_190 VGND VGND VPWR VPWR sky130_fd_sc_hd__decap_3
XFILLER_48_691 VGND VGND VPWR VPWR sky130_fd_sc_hd__fill_1
XFILLER_82_469 VGND VGND VPWR VPWR sky130_fd_sc_hd__decap_3
X_6902_ _6968_/CLK _6902_/D VGND VGND VPWR VPWR _6902_/Q sky130_fd_sc_hd__dfxtp_2
XFILLER_23_514 VGND VGND VPWR VPWR sky130_fd_sc_hd__decap_3
XFILLER_35_363 VGND VGND VPWR VPWR sky130_fd_sc_hd__decap_3
XFILLER_50_300 VGND VGND VPWR VPWR sky130_fd_sc_hd__decap_3
XFILLER_62_160 VGND VGND VPWR VPWR sky130_fd_sc_hd__decap_3
X_6833_ _6978_/CLK _6833_/D VGND VGND VPWR VPWR _6833_/Q sky130_fd_sc_hd__dfxtp_2
XTAP_TAPCELL_ROW_85_1275 VGND VPWR sky130_fd_sc_hd__tapvpwrvgnd_1
XFILLER_35_396 VGND VGND VPWR VPWR sky130_fd_sc_hd__fill_2
XFILLER_50_333 VGND VGND VPWR VPWR sky130_fd_sc_hd__decap_3
X_6764_ _6965_/CLK _6764_/D VGND VGND VPWR VPWR _6764_/Q sky130_fd_sc_hd__dfxtp_2
XFILLER_10_208 VGND VGND VPWR VPWR sky130_fd_sc_hd__decap_3
XFILLER_50_399 VGND VGND VPWR VPWR sky130_fd_sc_hd__fill_2
X_6695_ _7351_/CLK _6695_/D VGND VGND VPWR VPWR _6695_/Q sky130_fd_sc_hd__dfxtp_2
X_5715_ _7363_/Q hold920/X _5729_/S VGND VGND VPWR VPWR _6707_/D sky130_fd_sc_hd__mux2_2
XFILLER_109_608 VGND VGND VPWR VPWR sky130_fd_sc_hd__decap_3
X_5646_ _5646_/A VGND VGND VPWR VPWR _5646_/Y sky130_fd_sc_hd__inv_2
XPHY_EDGE_ROW_28_Left_145 VGND VGND VPWR VPWR sky130_fd_sc_hd__decap_3
XPHY_EDGE_ROW_93_Right_93 VGND VGND VPWR VPWR sky130_fd_sc_hd__decap_3
X_5577_ _5577_/A0 _5038_/X _5577_/S VGND VGND VPWR VPWR _7040_/D sky130_fd_sc_hd__mux2_2
XFILLER_104_302 VGND VGND VPWR VPWR sky130_fd_sc_hd__decap_3
XFILLER_2_429 VGND VGND VPWR VPWR sky130_fd_sc_hd__decap_3
X_7316_ clkload2/A _7316_/D _6596_/Y VGND VGND VPWR VPWR _7316_/Q sky130_fd_sc_hd__dfrtp_2
X_4528_ _4528_/A _4530_/S VGND VGND VPWR VPWR _7315_/D sky130_fd_sc_hd__or2_2
XFILLER_104_324 VGND VGND VPWR VPWR sky130_fd_sc_hd__decap_3
X_7247_ clkload7/A _7247_/D _6527_/Y VGND VGND VPWR VPWR _7247_/Q sky130_fd_sc_hd__dfrtp_2
X_4459_ _4040_/Y _4457_/X _4458_/X _3366_/X VGND VGND VPWR VPWR _5655_/B sky130_fd_sc_hd__o211a_2
XFILLER_104_357 VGND VGND VPWR VPWR sky130_fd_sc_hd__decap_3
XFILLER_104_368 VGND VGND VPWR VPWR sky130_fd_sc_hd__fill_2
XFILLER_104_379 VGND VGND VPWR VPWR sky130_fd_sc_hd__decap_3
XFILLER_49_48 VGND VGND VPWR VPWR sky130_fd_sc_hd__decap_3
X_7178_ _7338_/CLK _7178_/D _6458_/Y VGND VGND VPWR VPWR _7178_/Q sky130_fd_sc_hd__dfrtp_2
XFILLER_46_606 VGND VGND VPWR VPWR sky130_fd_sc_hd__fill_2
XFILLER_58_466 VGND VGND VPWR VPWR sky130_fd_sc_hd__decap_3
XPHY_EDGE_ROW_37_Left_154 VGND VGND VPWR VPWR sky130_fd_sc_hd__decap_3
XFILLER_105_87 VGND VGND VPWR VPWR sky130_fd_sc_hd__decap_3
XFILLER_45_116 VGND VGND VPWR VPWR sky130_fd_sc_hd__decap_3
XFILLER_58_477 VGND VGND VPWR VPWR sky130_fd_sc_hd__decap_3
XFILLER_65_47 VGND VGND VPWR VPWR sky130_fd_sc_hd__decap_3
XFILLER_73_425 VGND VGND VPWR VPWR sky130_fd_sc_hd__decap_3
XFILLER_45_149 VGND VGND VPWR VPWR sky130_fd_sc_hd__decap_3
XFILLER_73_469 VGND VGND VPWR VPWR sky130_fd_sc_hd__decap_3
XFILLER_85_296 VGND VGND VPWR VPWR sky130_fd_sc_hd__decap_3
XFILLER_26_341 VGND VGND VPWR VPWR sky130_fd_sc_hd__decap_3
XFILLER_26_374 VGND VGND VPWR VPWR sky130_fd_sc_hd__fill_2
XFILLER_81_491 VGND VGND VPWR VPWR sky130_fd_sc_hd__decap_3
XFILLER_81_57 VGND VGND VPWR VPWR sky130_fd_sc_hd__decap_3
XTAP_TAPCELL_ROW_24_542 VGND VPWR sky130_fd_sc_hd__tapvpwrvgnd_1
XFILLER_14_62 VGND VGND VPWR VPWR sky130_fd_sc_hd__decap_3
XFILLER_41_399 VGND VGND VPWR VPWR sky130_fd_sc_hd__decap_3
XTAP_TAPCELL_ROW_52_873 VGND VPWR sky130_fd_sc_hd__tapvpwrvgnd_1
XPHY_EDGE_ROW_46_Left_163 VGND VGND VPWR VPWR sky130_fd_sc_hd__decap_3
XFILLER_5_245 VGND VGND VPWR VPWR sky130_fd_sc_hd__decap_3
XFILLER_107_162 VGND VGND VPWR VPWR sky130_fd_sc_hd__decap_3
XFILLER_30_61 VGND VGND VPWR VPWR sky130_fd_sc_hd__decap_3
XFILLER_30_94 VGND VGND VPWR VPWR sky130_fd_sc_hd__decap_3
XFILLER_110_305 VGND VGND VPWR VPWR sky130_fd_sc_hd__decap_3
XPHY_EDGE_ROW_55_Left_172 VGND VGND VPWR VPWR sky130_fd_sc_hd__decap_3
XFILLER_110_349 VGND VGND VPWR VPWR sky130_fd_sc_hd__fill_2
XFILLER_1_484 VGND VGND VPWR VPWR sky130_fd_sc_hd__fill_1
XFILLER_49_422 VGND VGND VPWR VPWR sky130_fd_sc_hd__decap_3
XFILLER_96_539 VGND VGND VPWR VPWR sky130_fd_sc_hd__decap_3
XFILLER_76_241 VGND VGND VPWR VPWR sky130_fd_sc_hd__decap_3
XFILLER_36_116 VGND VGND VPWR VPWR sky130_fd_sc_hd__decap_3
XFILLER_37_617 VGND VGND VPWR VPWR sky130_fd_sc_hd__fill_1
XFILLER_64_403 VGND VGND VPWR VPWR sky130_fd_sc_hd__fill_2
XFILLER_76_285 VGND VGND VPWR VPWR sky130_fd_sc_hd__decap_3
XFILLER_29_190 VGND VGND VPWR VPWR sky130_fd_sc_hd__decap_3
XFILLER_36_138 VGND VGND VPWR VPWR sky130_fd_sc_hd__fill_2
XFILLER_36_149 VGND VGND VPWR VPWR sky130_fd_sc_hd__decap_3
XFILLER_51_119 VGND VGND VPWR VPWR sky130_fd_sc_hd__fill_1
XFILLER_55_80 VGND VGND VPWR VPWR sky130_fd_sc_hd__decap_3
XFILLER_17_396 VGND VGND VPWR VPWR sky130_fd_sc_hd__decap_3
XFILLER_44_160 VGND VGND VPWR VPWR sky130_fd_sc_hd__decap_3
XFILLER_32_355 VGND VGND VPWR VPWR sky130_fd_sc_hd__fill_2
XFILLER_44_193 VGND VGND VPWR VPWR sky130_fd_sc_hd__decap_3
X_3830_ _6860_/Q _3913_/A2 _3906_/B1 _6852_/Q _3829_/X VGND VGND VPWR VPWR _3830_/X
+ sky130_fd_sc_hd__a221o_2
XPHY_EDGE_ROW_64_Left_181 VGND VGND VPWR VPWR sky130_fd_sc_hd__decap_3
XFILLER_32_377 VGND VGND VPWR VPWR sky130_fd_sc_hd__decap_3
XFILLER_72_3 VGND VGND VPWR VPWR sky130_fd_sc_hd__decap_3
X_6480_ _6644_/A VGND VGND VPWR VPWR _6480_/Y sky130_fd_sc_hd__inv_2
X_3692_ _6715_/Q _3826_/A2 _3827_/B1 _6893_/Q _3691_/X VGND VGND VPWR VPWR _3692_/X
+ sky130_fd_sc_hd__a221o_2
X_5362_ _3378_/A _5646_/A _5362_/C VGND VGND VPWR VPWR _5398_/S sky130_fd_sc_hd__and3b_2
X_7101_ clkload6/A _7101_/D _6381_/Y VGND VGND VPWR VPWR _7101_/Q sky130_fd_sc_hd__dfrtp_2
X_4313_ _4376_/A _4364_/A _4364_/B _4313_/D VGND VGND VPWR VPWR _4315_/A sky130_fd_sc_hd__or4_4
XPHY_EDGE_ROW_73_Left_190 VGND VGND VPWR VPWR sky130_fd_sc_hd__decap_3
XFILLER_101_305 VGND VGND VPWR VPWR sky130_fd_sc_hd__decap_3
XFILLER_113_154 VGND VGND VPWR VPWR sky130_fd_sc_hd__decap_3
X_7032_ clkload1/A _7032_/D _6312_/Y VGND VGND VPWR VPWR _7032_/Q sky130_fd_sc_hd__dfrtp_2
XFILLER_99_388 VGND VGND VPWR VPWR sky130_fd_sc_hd__decap_3
XFILLER_99_355 VGND VGND VPWR VPWR sky130_fd_sc_hd__decap_3
XFILLER_113_198 VGND VGND VPWR VPWR sky130_fd_sc_hd__decap_3
XFILLER_19_29 VGND VGND VPWR VPWR sky130_fd_sc_hd__fill_1
X_4244_ _7293_/Q _4510_/S VGND VGND VPWR VPWR _4244_/X sky130_fd_sc_hd__and2_2
XFILLER_95_550 VGND VGND VPWR VPWR sky130_fd_sc_hd__decap_3
XFILLER_95_561 VGND VGND VPWR VPWR sky130_fd_sc_hd__decap_3
X_4175_ _7328_/Q _3964_/S _4188_/C1 _4174_/X VGND VGND VPWR VPWR _4175_/X sky130_fd_sc_hd__a211o_2
XFILLER_27_116 VGND VGND VPWR VPWR sky130_fd_sc_hd__decap_3
XFILLER_55_403 VGND VGND VPWR VPWR sky130_fd_sc_hd__decap_3
XFILLER_82_200 VGND VGND VPWR VPWR sky130_fd_sc_hd__decap_3
XFILLER_27_149 VGND VGND VPWR VPWR sky130_fd_sc_hd__decap_3
XFILLER_55_436 VGND VGND VPWR VPWR sky130_fd_sc_hd__decap_3
XFILLER_55_458 VGND VGND VPWR VPWR sky130_fd_sc_hd__decap_3
XFILLER_67_296 VGND VGND VPWR VPWR sky130_fd_sc_hd__decap_3
XFILLER_82_244 VGND VGND VPWR VPWR sky130_fd_sc_hd__decap_3
XFILLER_35_39 VGND VGND VPWR VPWR sky130_fd_sc_hd__decap_3
XFILLER_70_406 VGND VGND VPWR VPWR sky130_fd_sc_hd__decap_3
XFILLER_23_333 VGND VGND VPWR VPWR sky130_fd_sc_hd__decap_3
XFILLER_23_366 VGND VGND VPWR VPWR sky130_fd_sc_hd__decap_3
XFILLER_50_130 VGND VGND VPWR VPWR sky130_fd_sc_hd__decap_3
XFILLER_50_141 VGND VGND VPWR VPWR sky130_fd_sc_hd__decap_3
X_6816_ _6976_/CLK _6816_/D VGND VGND VPWR VPWR _6816_/Q sky130_fd_sc_hd__dfxtp_2
XFILLER_23_388 VGND VGND VPWR VPWR sky130_fd_sc_hd__decap_3
XFILLER_23_399 VGND VGND VPWR VPWR sky130_fd_sc_hd__decap_3
XFILLER_50_174 VGND VGND VPWR VPWR sky130_fd_sc_hd__decap_3
X_6747_ _6976_/CLK _6747_/D VGND VGND VPWR VPWR _6747_/Q sky130_fd_sc_hd__dfxtp_2
XTAP_TAPCELL_ROW_21_501 VGND VPWR sky130_fd_sc_hd__tapvpwrvgnd_1
XFILLER_109_405 VGND VGND VPWR VPWR sky130_fd_sc_hd__decap_3
XTAP_TAPCELL_ROW_98_1422 VGND VPWR sky130_fd_sc_hd__tapvpwrvgnd_1
X_6678_ _6684_/A VGND VGND VPWR VPWR _6678_/Y sky130_fd_sc_hd__inv_2
XTAP_TAPCELL_ROW_98_1433 VGND VPWR sky130_fd_sc_hd__tapvpwrvgnd_1
XFILLER_109_449 VGND VGND VPWR VPWR sky130_fd_sc_hd__decap_3
XFILLER_105_611 VGND VGND VPWR VPWR sky130_fd_sc_hd__decap_3
XFILLER_105_644 VGND VGND VPWR VPWR sky130_fd_sc_hd__decap_3
XFILLER_4_6 VGND VGND VPWR VPWR sky130_fd_sc_hd__fill_1
XFILLER_104_132 VGND VGND VPWR VPWR sky130_fd_sc_hd__decap_3
XFILLER_78_528 VGND VGND VPWR VPWR sky130_fd_sc_hd__decap_3
XFILLER_116_97 VGND VGND VPWR VPWR sky130_fd_sc_hd__decap_3
XFILLER_58_230 VGND VGND VPWR VPWR sky130_fd_sc_hd__decap_3
XFILLER_76_35 VGND VGND VPWR VPWR sky130_fd_sc_hd__decap_3
XFILLER_100_360 VGND VGND VPWR VPWR sky130_fd_sc_hd__decap_3
XFILLER_100_371 VGND VGND VPWR VPWR sky130_fd_sc_hd__decap_3
XFILLER_19_617 VGND VGND VPWR VPWR sky130_fd_sc_hd__decap_3
XFILLER_58_285 VGND VGND VPWR VPWR sky130_fd_sc_hd__fill_1
XFILLER_76_68 VGND VGND VPWR VPWR sky130_fd_sc_hd__decap_3
XTAP_TAPCELL_ROW_29_601 VGND VPWR sky130_fd_sc_hd__tapvpwrvgnd_1
XTAP_TAPCELL_ROW_57_932 VGND VPWR sky130_fd_sc_hd__tapvpwrvgnd_1
XFILLER_73_266 VGND VGND VPWR VPWR sky130_fd_sc_hd__decap_3
XTAP_TAPCELL_ROW_107_1540 VGND VPWR sky130_fd_sc_hd__tapvpwrvgnd_1
XFILLER_26_182 VGND VGND VPWR VPWR sky130_fd_sc_hd__decap_3
XFILLER_54_480 VGND VGND VPWR VPWR sky130_fd_sc_hd__decap_3
XFILLER_92_67 VGND VGND VPWR VPWR sky130_fd_sc_hd__decap_3
XFILLER_14_399 VGND VGND VPWR VPWR sky130_fd_sc_hd__decap_3
XFILLER_41_60 VGND VGND VPWR VPWR sky130_fd_sc_hd__decap_3
XFILLER_108_471 VGND VGND VPWR VPWR sky130_fd_sc_hd__decap_3
XFILLER_6_587 VGND VGND VPWR VPWR sky130_fd_sc_hd__fill_1
XFILLER_69_517 VGND VGND VPWR VPWR sky130_fd_sc_hd__decap_3
XTAP_TAPCELL_ROW_71_1105 VGND VPWR sky130_fd_sc_hd__tapvpwrvgnd_1
XFILLER_111_625 VGND VGND VPWR VPWR sky130_fd_sc_hd__decap_3
XFILLER_37_6 VGND VGND VPWR VPWR sky130_fd_sc_hd__fill_2
XFILLER_96_336 VGND VGND VPWR VPWR sky130_fd_sc_hd__decap_3
XFILLER_110_124 VGND VGND VPWR VPWR sky130_fd_sc_hd__decap_3
XFILLER_111_658 VGND VGND VPWR VPWR sky130_fd_sc_hd__fill_1
XFILLER_1_281 VGND VGND VPWR VPWR sky130_fd_sc_hd__fill_1
XFILLER_2_21 VGND VGND VPWR VPWR sky130_fd_sc_hd__decap_3
XFILLER_49_241 VGND VGND VPWR VPWR sky130_fd_sc_hd__decap_3
XFILLER_37_403 VGND VGND VPWR VPWR sky130_fd_sc_hd__decap_3
XFILLER_37_414 VGND VGND VPWR VPWR sky130_fd_sc_hd__decap_3
XFILLER_64_200 VGND VGND VPWR VPWR sky130_fd_sc_hd__fill_1
XFILLER_77_583 VGND VGND VPWR VPWR sky130_fd_sc_hd__decap_3
XFILLER_37_458 VGND VGND VPWR VPWR sky130_fd_sc_hd__decap_3
XFILLER_49_296 VGND VGND VPWR VPWR sky130_fd_sc_hd__decap_3
XFILLER_64_211 VGND VGND VPWR VPWR sky130_fd_sc_hd__decap_3
XFILLER_92_542 VGND VGND VPWR VPWR sky130_fd_sc_hd__decap_3
XFILLER_64_277 VGND VGND VPWR VPWR sky130_fd_sc_hd__decap_3
XFILLER_92_575 VGND VGND VPWR VPWR sky130_fd_sc_hd__decap_3
XTAP_TAPCELL_ROW_69_1078 VGND VPWR sky130_fd_sc_hd__tapvpwrvgnd_1
XFILLER_24_119 VGND VGND VPWR VPWR sky130_fd_sc_hd__decap_3
XFILLER_52_439 VGND VGND VPWR VPWR sky130_fd_sc_hd__decap_3
XFILLER_64_299 VGND VGND VPWR VPWR sky130_fd_sc_hd__decap_3
X_4931_ _4931_/A _4931_/B VGND VGND VPWR VPWR _6996_/D sky130_fd_sc_hd__nor2_2
XFILLER_32_130 VGND VGND VPWR VPWR sky130_fd_sc_hd__decap_3
XFILLER_32_141 VGND VGND VPWR VPWR sky130_fd_sc_hd__decap_3
XFILLER_33_642 VGND VGND VPWR VPWR sky130_fd_sc_hd__decap_3
X_4862_ _4825_/B _4862_/B VGND VGND VPWR VPWR _7000_/D sky130_fd_sc_hd__and2b_2
XTAP_TAPCELL_ROW_82_1234 VGND VPWR sky130_fd_sc_hd__tapvpwrvgnd_1
XFILLER_60_472 VGND VGND VPWR VPWR sky130_fd_sc_hd__decap_3
XFILLER_60_483 VGND VGND VPWR VPWR sky130_fd_sc_hd__decap_3
X_6601_ _6637_/A VGND VGND VPWR VPWR _6601_/Y sky130_fd_sc_hd__inv_2
X_3813_ _3802_/X _3812_/X _5151_/A VGND VGND VPWR VPWR _3813_/Y sky130_fd_sc_hd__o21ai_2
XANTENNA_15 _6728_/D VGND VGND VPWR VPWR sky130_fd_sc_hd__diode_2
XANTENNA_26 _4393_/X VGND VGND VPWR VPWR sky130_fd_sc_hd__diode_2
XFILLER_20_336 VGND VGND VPWR VPWR sky130_fd_sc_hd__decap_3
X_4793_ _4793_/A0 _4792_/X _4793_/S VGND VGND VPWR VPWR _7274_/D sky130_fd_sc_hd__mux2_2
X_6532_ _6532_/A VGND VGND VPWR VPWR _6532_/Y sky130_fd_sc_hd__inv_2
X_3744_ _6728_/Q _3890_/A2 _3890_/B1 _6973_/Q VGND VGND VPWR VPWR _3744_/X sky130_fd_sc_hd__a22o_2
XFILLER_9_370 VGND VGND VPWR VPWR sky130_fd_sc_hd__decap_3
X_6463_ _6672_/A VGND VGND VPWR VPWR _6463_/Y sky130_fd_sc_hd__inv_2
XFILLER_114_430 VGND VGND VPWR VPWR sky130_fd_sc_hd__decap_3
X_6394_ _6553_/A VGND VGND VPWR VPWR _6394_/Y sky130_fd_sc_hd__inv_2
XFILLER_114_452 VGND VGND VPWR VPWR sky130_fd_sc_hd__decap_3
XTAP_TAPCELL_ROW_93_1363 VGND VPWR sky130_fd_sc_hd__tapvpwrvgnd_1
XFILLER_99_141 VGND VGND VPWR VPWR sky130_fd_sc_hd__decap_3
XFILLER_101_113 VGND VGND VPWR VPWR sky130_fd_sc_hd__decap_3
XFILLER_87_314 VGND VGND VPWR VPWR sky130_fd_sc_hd__decap_3
X_5276_ hold998/X _5094_/X _5292_/S VGND VGND VPWR VPWR _7192_/D sky130_fd_sc_hd__mux2_2
X_7015_ _7258_/CLK _7015_/D _6295_/Y VGND VGND VPWR VPWR _7015_/Q sky130_fd_sc_hd__dfrtp_2
X_4227_ _7355_/Q _4270_/B _4334_/B1 _7163_/Q VGND VGND VPWR VPWR _4227_/X sky130_fd_sc_hd__a22o_2
XFILLER_101_157 VGND VGND VPWR VPWR sky130_fd_sc_hd__decap_3
XFILLER_68_572 VGND VGND VPWR VPWR sky130_fd_sc_hd__decap_3
XFILLER_28_458 VGND VGND VPWR VPWR sky130_fd_sc_hd__decap_3
XFILLER_46_49 VGND VGND VPWR VPWR sky130_fd_sc_hd__decap_3
XFILLER_55_222 VGND VGND VPWR VPWR sky130_fd_sc_hd__fill_2
XFILLER_83_520 VGND VGND VPWR VPWR sky130_fd_sc_hd__decap_3
X_4158_ _4158_/A _4158_/B VGND VGND VPWR VPWR _4920_/A sky130_fd_sc_hd__nand2_2
XFILLER_55_255 VGND VGND VPWR VPWR sky130_fd_sc_hd__decap_3
XFILLER_83_564 VGND VGND VPWR VPWR sky130_fd_sc_hd__decap_3
X_4089_ _7206_/Q _3947_/S _4437_/B1 _7398_/Q VGND VGND VPWR VPWR _4089_/X sky130_fd_sc_hd__a22o_2
XTAP_TAPCELL_ROW_54_902 VGND VPWR sky130_fd_sc_hd__tapvpwrvgnd_1
XFILLER_102_22 VGND VGND VPWR VPWR sky130_fd_sc_hd__decap_3
XFILLER_15_119 VGND VGND VPWR VPWR sky130_fd_sc_hd__decap_3
XFILLER_43_428 VGND VGND VPWR VPWR sky130_fd_sc_hd__decap_3
XFILLER_70_214 VGND VGND VPWR VPWR sky130_fd_sc_hd__decap_3
XFILLER_83_597 VGND VGND VPWR VPWR sky130_fd_sc_hd__decap_3
XFILLER_102_88 VGND VGND VPWR VPWR sky130_fd_sc_hd__decap_3
XFILLER_70_247 VGND VGND VPWR VPWR sky130_fd_sc_hd__decap_3
XFILLER_23_152 VGND VGND VPWR VPWR sky130_fd_sc_hd__decap_3
XFILLER_51_461 VGND VGND VPWR VPWR sky130_fd_sc_hd__decap_3
XTAP_TAPCELL_ROW_62_990 VGND VPWR sky130_fd_sc_hd__tapvpwrvgnd_1
XTAP_TAPCELL_ROW_102_1481 VGND VPWR sky130_fd_sc_hd__tapvpwrvgnd_1
XTAP_TAPCELL_ROW_102_1470 VGND VPWR sky130_fd_sc_hd__tapvpwrvgnd_1
XFILLER_11_358 VGND VGND VPWR VPWR sky130_fd_sc_hd__decap_3
XFILLER_109_246 VGND VGND VPWR VPWR sky130_fd_sc_hd__decap_3
XFILLER_109_279 VGND VGND VPWR VPWR sky130_fd_sc_hd__fill_1
XFILLER_11_63 VGND VGND VPWR VPWR sky130_fd_sc_hd__decap_3
XFILLER_105_452 VGND VGND VPWR VPWR sky130_fd_sc_hd__decap_3
XFILLER_11_96 VGND VGND VPWR VPWR sky130_fd_sc_hd__decap_3
XFILLER_87_12 VGND VGND VPWR VPWR sky130_fd_sc_hd__decap_3
XFILLER_105_485 VGND VGND VPWR VPWR sky130_fd_sc_hd__decap_3
XFILLER_78_347 VGND VGND VPWR VPWR sky130_fd_sc_hd__fill_1
XFILLER_19_414 VGND VGND VPWR VPWR sky130_fd_sc_hd__decap_3
XFILLER_46_200 VGND VGND VPWR VPWR sky130_fd_sc_hd__decap_3
XFILLER_59_572 VGND VGND VPWR VPWR sky130_fd_sc_hd__decap_3
XFILLER_93_328 VGND VGND VPWR VPWR sky130_fd_sc_hd__decap_3
XFILLER_46_233 VGND VGND VPWR VPWR sky130_fd_sc_hd__decap_3
XFILLER_74_520 VGND VGND VPWR VPWR sky130_fd_sc_hd__fill_2
XFILLER_74_542 VGND VGND VPWR VPWR sky130_fd_sc_hd__decap_3
XFILLER_86_380 VGND VGND VPWR VPWR sky130_fd_sc_hd__decap_3
XFILLER_74_575 VGND VGND VPWR VPWR sky130_fd_sc_hd__decap_3
XFILLER_34_417 VGND VGND VPWR VPWR sky130_fd_sc_hd__fill_1
XFILLER_61_214 VGND VGND VPWR VPWR sky130_fd_sc_hd__fill_2
XFILLER_61_225 VGND VGND VPWR VPWR sky130_fd_sc_hd__decap_3
XFILLER_61_247 VGND VGND VPWR VPWR sky130_fd_sc_hd__decap_3
XFILLER_14_174 VGND VGND VPWR VPWR sky130_fd_sc_hd__decap_3
Xhold808 _6764_/Q VGND VGND VPWR VPWR _6764_/D sky130_fd_sc_hd__dlygate4sd3_1
Xhold819 _6958_/Q VGND VGND VPWR VPWR _6958_/D sky130_fd_sc_hd__dlygate4sd3_1
XTAP_TAPCELL_ROW_12_397 VGND VPWR sky130_fd_sc_hd__tapvpwrvgnd_1
XTAP_TAPCELL_ROW_116_1639 VGND VPWR sky130_fd_sc_hd__tapvpwrvgnd_1
X_3460_ _7313_/Q _3994_/S _4338_/B1 _7345_/Q _4248_/A VGND VGND VPWR VPWR _3460_/X
+ sky130_fd_sc_hd__a221o_2
XFILLER_97_601 VGND VGND VPWR VPWR sky130_fd_sc_hd__decap_3
X_3391_ _7251_/Q _4601_/S _3390_/X VGND VGND VPWR VPWR _3589_/A sky130_fd_sc_hd__a21oi_2
XFILLER_69_325 VGND VGND VPWR VPWR sky130_fd_sc_hd__decap_3
XFILLER_96_100 VGND VGND VPWR VPWR sky130_fd_sc_hd__decap_3
XFILLER_97_623 VGND VGND VPWR VPWR sky130_fd_sc_hd__decap_3
X_5130_ _5130_/A _5670_/B _5130_/C VGND VGND VPWR VPWR _6982_/D sky130_fd_sc_hd__nor3_2
XFILLER_111_444 VGND VGND VPWR VPWR sky130_fd_sc_hd__decap_3
XFILLER_69_358 VGND VGND VPWR VPWR sky130_fd_sc_hd__decap_3
XFILLER_69_369 VGND VGND VPWR VPWR sky130_fd_sc_hd__decap_3
XFILLER_96_133 VGND VGND VPWR VPWR sky130_fd_sc_hd__decap_3
XFILLER_96_144 VGND VGND VPWR VPWR sky130_fd_sc_hd__decap_3
X_5061_ _6988_/D _5060_/X _5156_/S VGND VGND VPWR VPWR _5061_/X sky130_fd_sc_hd__mux2_2
XFILLER_111_466 VGND VGND VPWR VPWR sky130_fd_sc_hd__fill_2
XFILLER_111_477 VGND VGND VPWR VPWR sky130_fd_sc_hd__decap_3
XFILLER_84_306 VGND VGND VPWR VPWR sky130_fd_sc_hd__fill_2
XFILLER_96_177 VGND VGND VPWR VPWR sky130_fd_sc_hd__decap_3
XFILLER_37_200 VGND VGND VPWR VPWR sky130_fd_sc_hd__decap_3
XFILLER_25_406 VGND VGND VPWR VPWR sky130_fd_sc_hd__decap_3
XFILLER_80_501 VGND VGND VPWR VPWR sky130_fd_sc_hd__decap_3
XFILLER_92_361 VGND VGND VPWR VPWR sky130_fd_sc_hd__decap_3
XFILLER_18_480 VGND VGND VPWR VPWR sky130_fd_sc_hd__fill_1
XFILLER_37_299 VGND VGND VPWR VPWR sky130_fd_sc_hd__decap_3
XFILLER_52_214 VGND VGND VPWR VPWR sky130_fd_sc_hd__fill_1
XFILLER_52_225 VGND VGND VPWR VPWR sky130_fd_sc_hd__decap_3
XFILLER_80_545 VGND VGND VPWR VPWR sky130_fd_sc_hd__decap_3
XFILLER_80_567 VGND VGND VPWR VPWR sky130_fd_sc_hd__fill_1
X_4914_ _4914_/A0 _4913_/X _4946_/S VGND VGND VPWR VPWR _7267_/D sky130_fd_sc_hd__mux2_2
XFILLER_33_461 VGND VGND VPWR VPWR sky130_fd_sc_hd__decap_3
XFILLER_80_578 VGND VGND VPWR VPWR sky130_fd_sc_hd__decap_3
XFILLER_80_589 VGND VGND VPWR VPWR sky130_fd_sc_hd__decap_3
XFILLER_20_111 VGND VGND VPWR VPWR sky130_fd_sc_hd__decap_3
XFILLER_32_29 VGND VGND VPWR VPWR sky130_fd_sc_hd__decap_3
X_4845_ _4845_/A VGND VGND VPWR VPWR _4872_/A sky130_fd_sc_hd__inv_2
XFILLER_20_144 VGND VGND VPWR VPWR sky130_fd_sc_hd__decap_3
X_4776_ _7004_/Q _4804_/A VGND VGND VPWR VPWR _4777_/C sky130_fd_sc_hd__or2_2
XFILLER_20_177 VGND VGND VPWR VPWR sky130_fd_sc_hd__decap_3
X_6515_ _6611_/A VGND VGND VPWR VPWR _6515_/Y sky130_fd_sc_hd__inv_2
X_3727_ _3746_/B _3733_/C VGND VGND VPWR VPWR _3728_/B sky130_fd_sc_hd__nand2_2
X_6446_ _6606_/A VGND VGND VPWR VPWR _6446_/Y sky130_fd_sc_hd__inv_2
XFILLER_106_249 VGND VGND VPWR VPWR sky130_fd_sc_hd__decap_3
X_6377_ _6539_/A VGND VGND VPWR VPWR _6377_/Y sky130_fd_sc_hd__inv_2
X_3589_ _3589_/A _3589_/B VGND VGND VPWR VPWR _3590_/B sky130_fd_sc_hd__nor2_2
XFILLER_102_411 VGND VGND VPWR VPWR sky130_fd_sc_hd__decap_3
XFILLER_88_634 VGND VGND VPWR VPWR sky130_fd_sc_hd__decap_3
XFILLER_102_433 VGND VGND VPWR VPWR sky130_fd_sc_hd__decap_3
XFILLER_57_15 VGND VGND VPWR VPWR sky130_fd_sc_hd__decap_3
XFILLER_88_645 VGND VGND VPWR VPWR sky130_fd_sc_hd__fill_2
XFILLER_88_656 VGND VGND VPWR VPWR sky130_fd_sc_hd__decap_3
XFILLER_102_477 VGND VGND VPWR VPWR sky130_fd_sc_hd__decap_3
XFILLER_57_37 VGND VGND VPWR VPWR sky130_fd_sc_hd__decap_3
XFILLER_102_499 VGND VGND VPWR VPWR sky130_fd_sc_hd__decap_3
XFILLER_28_200 VGND VGND VPWR VPWR sky130_fd_sc_hd__decap_3
XFILLER_68_380 VGND VGND VPWR VPWR sky130_fd_sc_hd__decap_3
XFILLER_87_188 VGND VGND VPWR VPWR sky130_fd_sc_hd__decap_3
XFILLER_113_54 VGND VGND VPWR VPWR sky130_fd_sc_hd__fill_2
XFILLER_90_309 VGND VGND VPWR VPWR sky130_fd_sc_hd__decap_3
XFILLER_113_87 VGND VGND VPWR VPWR sky130_fd_sc_hd__decap_3
XFILLER_16_439 VGND VGND VPWR VPWR sky130_fd_sc_hd__decap_3
XFILLER_28_277 VGND VGND VPWR VPWR sky130_fd_sc_hd__decap_3
XFILLER_43_225 VGND VGND VPWR VPWR sky130_fd_sc_hd__fill_2
XFILLER_71_534 VGND VGND VPWR VPWR sky130_fd_sc_hd__decap_3
XFILLER_73_25 VGND VGND VPWR VPWR sky130_fd_sc_hd__decap_3
XFILLER_83_361 VGND VGND VPWR VPWR sky130_fd_sc_hd__decap_3
XFILLER_71_567 VGND VGND VPWR VPWR sky130_fd_sc_hd__decap_3
XFILLER_73_69 VGND VGND VPWR VPWR sky130_fd_sc_hd__decap_3
XFILLER_43_269 VGND VGND VPWR VPWR sky130_fd_sc_hd__decap_3
XFILLER_11_111 VGND VGND VPWR VPWR sky130_fd_sc_hd__fill_1
XFILLER_11_122 VGND VGND VPWR VPWR sky130_fd_sc_hd__decap_3
XFILLER_12_623 VGND VGND VPWR VPWR sky130_fd_sc_hd__fill_1
XFILLER_11_155 VGND VGND VPWR VPWR sky130_fd_sc_hd__decap_3
XFILLER_7_104 VGND VGND VPWR VPWR sky130_fd_sc_hd__decap_3
XFILLER_8_616 VGND VGND VPWR VPWR sky130_fd_sc_hd__decap_3
XFILLER_7_137 VGND VGND VPWR VPWR sky130_fd_sc_hd__fill_2
XFILLER_7_148 VGND VGND VPWR VPWR sky130_fd_sc_hd__decap_3
XFILLER_22_62 VGND VGND VPWR VPWR sky130_fd_sc_hd__decap_3
XFILLER_98_22 VGND VGND VPWR VPWR sky130_fd_sc_hd__fill_1
XFILLER_98_66 VGND VGND VPWR VPWR sky130_fd_sc_hd__decap_3
XFILLER_105_260 VGND VGND VPWR VPWR sky130_fd_sc_hd__decap_3
XFILLER_78_100 VGND VGND VPWR VPWR sky130_fd_sc_hd__decap_3
XFILLER_79_623 VGND VGND VPWR VPWR sky130_fd_sc_hd__decap_3
XFILLER_98_88 VGND VGND VPWR VPWR sky130_fd_sc_hd__decap_3
XFILLER_105_293 VGND VGND VPWR VPWR sky130_fd_sc_hd__decap_3
XFILLER_78_144 VGND VGND VPWR VPWR sky130_fd_sc_hd__decap_3
XFILLER_79_656 VGND VGND VPWR VPWR sky130_fd_sc_hd__decap_3
XFILLER_21_9 VGND VGND VPWR VPWR sky130_fd_sc_hd__fill_1
XFILLER_66_317 VGND VGND VPWR VPWR sky130_fd_sc_hd__fill_1
XFILLER_78_155 VGND VGND VPWR VPWR sky130_fd_sc_hd__decap_3
XFILLER_93_103 VGND VGND VPWR VPWR sky130_fd_sc_hd__decap_3
XFILLER_94_615 VGND VGND VPWR VPWR sky130_fd_sc_hd__decap_3
XFILLER_19_200 VGND VGND VPWR VPWR sky130_fd_sc_hd__decap_3
XFILLER_19_222 VGND VGND VPWR VPWR sky130_fd_sc_hd__fill_2
XFILLER_59_380 VGND VGND VPWR VPWR sky130_fd_sc_hd__decap_3
XFILLER_78_188 VGND VGND VPWR VPWR sky130_fd_sc_hd__decap_3
XFILLER_94_648 VGND VGND VPWR VPWR sky130_fd_sc_hd__decap_3
XFILLER_19_255 VGND VGND VPWR VPWR sky130_fd_sc_hd__decap_3
XFILLER_74_350 VGND VGND VPWR VPWR sky130_fd_sc_hd__decap_3
XFILLER_81_309 VGND VGND VPWR VPWR sky130_fd_sc_hd__decap_3
XFILLER_93_158 VGND VGND VPWR VPWR sky130_fd_sc_hd__decap_3
XFILLER_93_169 VGND VGND VPWR VPWR sky130_fd_sc_hd__decap_3
XFILLER_19_299 VGND VGND VPWR VPWR sky130_fd_sc_hd__decap_3
XFILLER_34_203 VGND VGND VPWR VPWR sky130_fd_sc_hd__fill_2
XFILLER_62_523 VGND VGND VPWR VPWR sky130_fd_sc_hd__decap_3
XTAP_TAPCELL_ROW_66_1048 VGND VPWR sky130_fd_sc_hd__tapvpwrvgnd_1
XFILLER_62_589 VGND VGND VPWR VPWR sky130_fd_sc_hd__decap_3
XTAP_TAPCELL_ROW_45_787 VGND VPWR sky130_fd_sc_hd__tapvpwrvgnd_1
XTAP_TAPCELL_ROW_17_456 VGND VPWR sky130_fd_sc_hd__tapvpwrvgnd_1
XFILLER_63_80 VGND VGND VPWR VPWR sky130_fd_sc_hd__decap_3
XFILLER_8_20 VGND VGND VPWR VPWR sky130_fd_sc_hd__decap_3
X_4630_ _4627_/Y _4629_/Y _4372_/A VGND VGND VPWR VPWR _4630_/X sky130_fd_sc_hd__a21o_2
XFILLER_30_475 VGND VGND VPWR VPWR sky130_fd_sc_hd__fill_1
XFILLER_30_486 VGND VGND VPWR VPWR sky130_fd_sc_hd__decap_3
XFILLER_8_97 VGND VGND VPWR VPWR sky130_fd_sc_hd__decap_3
X_6300_ _6366_/A VGND VGND VPWR VPWR _6300_/Y sky130_fd_sc_hd__inv_2
X_4561_ _4561_/A _4567_/B VGND VGND VPWR VPWR _7300_/D sky130_fd_sc_hd__and2_2
XFILLER_116_525 VGND VGND VPWR VPWR sky130_fd_sc_hd__decap_3
X_7280_ _7381_/CLK _7280_/D _6560_/Y VGND VGND VPWR VPWR _7280_/Q sky130_fd_sc_hd__dfrtp_2
Xhold605 _6887_/Q VGND VGND VPWR VPWR _6887_/D sky130_fd_sc_hd__dlygate4sd3_1
Xhold616 _6841_/Q VGND VGND VPWR VPWR _6841_/D sky130_fd_sc_hd__dlygate4sd3_1
Xhold627 _6906_/Q VGND VGND VPWR VPWR _6906_/D sky130_fd_sc_hd__dlygate4sd3_1
XFILLER_6_181 VGND VGND VPWR VPWR sky130_fd_sc_hd__fill_1
Xhold638 _6741_/Q VGND VGND VPWR VPWR _6741_/D sky130_fd_sc_hd__dlygate4sd3_1
Xhold649 _6886_/Q VGND VGND VPWR VPWR _6886_/D sky130_fd_sc_hd__dlygate4sd3_1
XTAP_TAPCELL_ROW_77_1177 VGND VPWR sky130_fd_sc_hd__tapvpwrvgnd_1
XFILLER_103_208 VGND VGND VPWR VPWR sky130_fd_sc_hd__decap_3
XTAP_TAPCELL_ROW_90_1333 VGND VPWR sky130_fd_sc_hd__tapvpwrvgnd_1
XFILLER_69_111 VGND VGND VPWR VPWR sky130_fd_sc_hd__fill_1
XFILLER_69_122 VGND VGND VPWR VPWR sky130_fd_sc_hd__decap_3
XFILLER_97_420 VGND VGND VPWR VPWR sky130_fd_sc_hd__decap_3
XFILLER_97_442 VGND VGND VPWR VPWR sky130_fd_sc_hd__fill_2
X_5113_ _5113_/A _5113_/B VGND VGND VPWR VPWR _5113_/Y sky130_fd_sc_hd__xnor2_2
XFILLER_57_317 VGND VGND VPWR VPWR sky130_fd_sc_hd__decap_3
XFILLER_69_155 VGND VGND VPWR VPWR sky130_fd_sc_hd__decap_3
XFILLER_84_103 VGND VGND VPWR VPWR sky130_fd_sc_hd__decap_3
XFILLER_85_604 VGND VGND VPWR VPWR sky130_fd_sc_hd__decap_3
XFILLER_97_464 VGND VGND VPWR VPWR sky130_fd_sc_hd__decap_3
XFILLER_111_285 VGND VGND VPWR VPWR sky130_fd_sc_hd__decap_3
XFILLER_69_199 VGND VGND VPWR VPWR sky130_fd_sc_hd__decap_3
XFILLER_84_136 VGND VGND VPWR VPWR sky130_fd_sc_hd__decap_3
XFILLER_85_637 VGND VGND VPWR VPWR sky130_fd_sc_hd__decap_3
XFILLER_97_497 VGND VGND VPWR VPWR sky130_fd_sc_hd__decap_3
X_5044_ _5044_/A _5044_/B VGND VGND VPWR VPWR _6988_/D sky130_fd_sc_hd__nor2_2
XFILLER_84_147 VGND VGND VPWR VPWR sky130_fd_sc_hd__decap_3
XFILLER_84_158 VGND VGND VPWR VPWR sky130_fd_sc_hd__decap_3
XFILLER_25_214 VGND VGND VPWR VPWR sky130_fd_sc_hd__decap_3
XFILLER_38_597 VGND VGND VPWR VPWR sky130_fd_sc_hd__fill_2
XFILLER_25_225 VGND VGND VPWR VPWR sky130_fd_sc_hd__decap_3
XFILLER_25_236 VGND VGND VPWR VPWR sky130_fd_sc_hd__decap_3
XFILLER_53_556 VGND VGND VPWR VPWR sky130_fd_sc_hd__decap_3
XFILLER_80_342 VGND VGND VPWR VPWR sky130_fd_sc_hd__decap_3
XFILLER_92_191 VGND VGND VPWR VPWR sky130_fd_sc_hd__decap_3
X_6995_ _7338_/CLK _6995_/D _6275_/Y VGND VGND VPWR VPWR _6995_/Q sky130_fd_sc_hd__dfrtp_2
XFILLER_25_269 VGND VGND VPWR VPWR sky130_fd_sc_hd__decap_3
XFILLER_40_206 VGND VGND VPWR VPWR sky130_fd_sc_hd__fill_2
XFILLER_43_17 VGND VGND VPWR VPWR sky130_fd_sc_hd__decap_3
XFILLER_80_353 VGND VGND VPWR VPWR sky130_fd_sc_hd__decap_3
XFILLER_80_397 VGND VGND VPWR VPWR sky130_fd_sc_hd__decap_3
X_4828_ _4891_/A1 _4810_/B _4827_/A _5033_/B2 VGND VGND VPWR VPWR _4828_/X sky130_fd_sc_hd__a22o_2
XFILLER_107_503 VGND VGND VPWR VPWR sky130_fd_sc_hd__fill_1
X_4759_ _4759_/A _4777_/B VGND VGND VPWR VPWR _4760_/B sky130_fd_sc_hd__xnor2_2
XFILLER_107_525 VGND VGND VPWR VPWR sky130_fd_sc_hd__decap_3
XFILLER_104_6 VGND VGND VPWR VPWR sky130_fd_sc_hd__decap_3
XFILLER_107_558 VGND VGND VPWR VPWR sky130_fd_sc_hd__fill_2
XFILLER_108_21 VGND VGND VPWR VPWR sky130_fd_sc_hd__decap_3
XFILLER_108_32 VGND VGND VPWR VPWR sky130_fd_sc_hd__decap_3
X_6429_ _6647_/A VGND VGND VPWR VPWR _6429_/Y sky130_fd_sc_hd__inv_2
XFILLER_108_54 VGND VGND VPWR VPWR sky130_fd_sc_hd__decap_3
XFILLER_68_14 VGND VGND VPWR VPWR sky130_fd_sc_hd__decap_3
XFILLER_68_25 VGND VGND VPWR VPWR sky130_fd_sc_hd__decap_3
XFILLER_68_47 VGND VGND VPWR VPWR sky130_fd_sc_hd__decap_3
XFILLER_0_368 VGND VGND VPWR VPWR sky130_fd_sc_hd__decap_3
XFILLER_102_241 VGND VGND VPWR VPWR sky130_fd_sc_hd__decap_3
XFILLER_48_306 VGND VGND VPWR VPWR sky130_fd_sc_hd__fill_2
XFILLER_76_626 VGND VGND VPWR VPWR sky130_fd_sc_hd__fill_2
XFILLER_88_486 VGND VGND VPWR VPWR sky130_fd_sc_hd__decap_3
XFILLER_102_274 VGND VGND VPWR VPWR sky130_fd_sc_hd__decap_3
XFILLER_48_339 VGND VGND VPWR VPWR sky130_fd_sc_hd__decap_3
XFILLER_76_637 VGND VGND VPWR VPWR sky130_fd_sc_hd__decap_3
XFILLER_76_648 VGND VGND VPWR VPWR sky130_fd_sc_hd__decap_3
XFILLER_29_553 VGND VGND VPWR VPWR sky130_fd_sc_hd__decap_3
XFILLER_75_169 VGND VGND VPWR VPWR sky130_fd_sc_hd__decap_3
XFILLER_84_24 VGND VGND VPWR VPWR sky130_fd_sc_hd__decap_3
XFILLER_16_203 VGND VGND VPWR VPWR sky130_fd_sc_hd__decap_3
XFILLER_84_79 VGND VGND VPWR VPWR sky130_fd_sc_hd__decap_3
XFILLER_90_106 VGND VGND VPWR VPWR sky130_fd_sc_hd__decap_3
Xplace309 _3586_/Y VGND VGND VPWR VPWR _3600_/A sky130_fd_sc_hd__buf_2
XFILLER_16_236 VGND VGND VPWR VPWR sky130_fd_sc_hd__decap_3
XFILLER_17_73 VGND VGND VPWR VPWR sky130_fd_sc_hd__decap_3
XFILLER_44_545 VGND VGND VPWR VPWR sky130_fd_sc_hd__decap_3
XFILLER_17_95 VGND VGND VPWR VPWR sky130_fd_sc_hd__decap_3
XFILLER_31_206 VGND VGND VPWR VPWR sky130_fd_sc_hd__decap_3
XFILLER_71_364 VGND VGND VPWR VPWR sky130_fd_sc_hd__fill_1
XFILLER_31_239 VGND VGND VPWR VPWR sky130_fd_sc_hd__decap_3
XTAP_TAPCELL_ROW_14_415 VGND VPWR sky130_fd_sc_hd__tapvpwrvgnd_1
XFILLER_8_413 VGND VGND VPWR VPWR sky130_fd_sc_hd__decap_3
XTAP_TAPCELL_ROW_42_757 VGND VPWR sky130_fd_sc_hd__tapvpwrvgnd_1
XFILLER_12_486 VGND VGND VPWR VPWR sky130_fd_sc_hd__fill_1
XFILLER_4_641 VGND VGND VPWR VPWR sky130_fd_sc_hd__decap_3
XTAP_TAPCELL_ROW_113_1609 VGND VPWR sky130_fd_sc_hd__tapvpwrvgnd_1
XFILLER_113_517 VGND VGND VPWR VPWR sky130_fd_sc_hd__decap_3
XFILLER_98_217 VGND VGND VPWR VPWR sky130_fd_sc_hd__decap_3
XFILLER_3_195 VGND VGND VPWR VPWR sky130_fd_sc_hd__decap_3
XFILLER_79_420 VGND VGND VPWR VPWR sky130_fd_sc_hd__decap_3
XFILLER_67_615 VGND VGND VPWR VPWR sky130_fd_sc_hd__fill_1
XFILLER_67_626 VGND VGND VPWR VPWR sky130_fd_sc_hd__fill_1
XFILLER_79_464 VGND VGND VPWR VPWR sky130_fd_sc_hd__decap_3
XFILLER_39_328 VGND VGND VPWR VPWR sky130_fd_sc_hd__decap_3
XFILLER_58_80 VGND VGND VPWR VPWR sky130_fd_sc_hd__decap_3
XFILLER_66_125 VGND VGND VPWR VPWR sky130_fd_sc_hd__decap_3
XFILLER_67_637 VGND VGND VPWR VPWR sky130_fd_sc_hd__decap_3
XFILLER_94_412 VGND VGND VPWR VPWR sky130_fd_sc_hd__decap_3
XFILLER_94_445 VGND VGND VPWR VPWR sky130_fd_sc_hd__fill_1
XFILLER_54_309 VGND VGND VPWR VPWR sky130_fd_sc_hd__decap_3
XFILLER_66_147 VGND VGND VPWR VPWR sky130_fd_sc_hd__decap_3
XFILLER_82_618 VGND VGND VPWR VPWR sky130_fd_sc_hd__decap_3
XFILLER_94_467 VGND VGND VPWR VPWR sky130_fd_sc_hd__decap_3
XFILLER_47_383 VGND VGND VPWR VPWR sky130_fd_sc_hd__decap_3
XFILLER_75_681 VGND VGND VPWR VPWR sky130_fd_sc_hd__decap_3
XFILLER_62_320 VGND VGND VPWR VPWR sky130_fd_sc_hd__decap_3
XFILLER_74_180 VGND VGND VPWR VPWR sky130_fd_sc_hd__decap_3
XFILLER_90_651 VGND VGND VPWR VPWR sky130_fd_sc_hd__decap_3
XFILLER_22_206 VGND VGND VPWR VPWR sky130_fd_sc_hd__decap_3
XFILLER_35_578 VGND VGND VPWR VPWR sky130_fd_sc_hd__decap_3
XFILLER_62_353 VGND VGND VPWR VPWR sky130_fd_sc_hd__decap_3
X_6780_ _6936_/CLK _6780_/D VGND VGND VPWR VPWR _6780_/Q sky130_fd_sc_hd__dfxtp_2
X_3992_ _5156_/S _5587_/B VGND VGND VPWR VPWR _3992_/Y sky130_fd_sc_hd__nand2_2
XFILLER_22_239 VGND VGND VPWR VPWR sky130_fd_sc_hd__decap_3
XFILLER_62_386 VGND VGND VPWR VPWR sky130_fd_sc_hd__decap_3
XFILLER_62_397 VGND VGND VPWR VPWR sky130_fd_sc_hd__decap_3
X_5731_ _7371_/Q hold921/X _5737_/S VGND VGND VPWR VPWR _6715_/D sky130_fd_sc_hd__mux2_2
X_5662_ _5662_/A _5662_/B _5662_/C _5661_/X VGND VGND VPWR VPWR _5663_/D sky130_fd_sc_hd__or4b_4
XFILLER_30_283 VGND VGND VPWR VPWR sky130_fd_sc_hd__decap_3
X_7401_ _7401_/CLK _7401_/D _6681_/Y VGND VGND VPWR VPWR _7401_/Q sky130_fd_sc_hd__dfrtp_2
X_5593_ _5593_/A _5595_/B VGND VGND VPWR VPWR _7031_/D sky130_fd_sc_hd__or2_2
X_4613_ _4614_/B _4613_/B _5113_/A VGND VGND VPWR VPWR _4617_/B sky130_fd_sc_hd__and3_2
X_7332_ _7364_/CLK _7332_/D _6612_/Y VGND VGND VPWR VPWR _7332_/Q sky130_fd_sc_hd__dfrtp_2
X_4544_ _4544_/A _4569_/B VGND VGND VPWR VPWR _7308_/D sky130_fd_sc_hd__and2_2
XFILLER_116_333 VGND VGND VPWR VPWR sky130_fd_sc_hd__decap_3
X_7263_ _7294_/CLK _7263_/D _6543_/Y VGND VGND VPWR VPWR _7263_/Q sky130_fd_sc_hd__dfrtp_2
XFILLER_104_517 VGND VGND VPWR VPWR sky130_fd_sc_hd__decap_3
XFILLER_116_388 VGND VGND VPWR VPWR sky130_fd_sc_hd__decap_3
XFILLER_116_399 VGND VGND VPWR VPWR sky130_fd_sc_hd__decap_3
X_7194_ _7360_/CLK _7194_/D _6474_/Y VGND VGND VPWR VPWR _7194_/Q sky130_fd_sc_hd__dfrtp_2
X_3426_ _3589_/A _3591_/A _3589_/B _3590_/C VGND VGND VPWR VPWR _3427_/B sky130_fd_sc_hd__or4_4
XFILLER_112_561 VGND VGND VPWR VPWR sky130_fd_sc_hd__decap_3
XFILLER_97_261 VGND VGND VPWR VPWR sky130_fd_sc_hd__decap_3
X_3357_ _4537_/B VGND VGND VPWR VPWR _3449_/A sky130_fd_sc_hd__inv_6
XFILLER_57_103 VGND VGND VPWR VPWR sky130_fd_sc_hd__fill_1
XFILLER_57_125 VGND VGND VPWR VPWR sky130_fd_sc_hd__decap_3
XFILLER_85_423 VGND VGND VPWR VPWR sky130_fd_sc_hd__decap_3
Xhold1102 _7317_/Q VGND VGND VPWR VPWR _4524_/A0 sky130_fd_sc_hd__dlygate4sd3_1
Xhold1113 _7303_/Q VGND VGND VPWR VPWR _4554_/A sky130_fd_sc_hd__dlygate4sd3_1
Xhold1124 _7181_/Q VGND VGND VPWR VPWR _5298_/A0 sky130_fd_sc_hd__dlygate4sd3_1
Xhold1135 _7130_/Q VGND VGND VPWR VPWR _5407_/A0 sky130_fd_sc_hd__dlygate4sd3_1
Xhold1146 _7394_/Q VGND VGND VPWR VPWR _3766_/A1 sky130_fd_sc_hd__dlygate4sd3_1
Xhold1157 _7149_/Q VGND VGND VPWR VPWR _5367_/A0 sky130_fd_sc_hd__dlygate4sd3_1
X_5027_ _5092_/C _5024_/X _6990_/D _5666_/A VGND VGND VPWR VPWR _5027_/X sky130_fd_sc_hd__a22o_2
XFILLER_38_350 VGND VGND VPWR VPWR sky130_fd_sc_hd__decap_3
XFILLER_72_128 VGND VGND VPWR VPWR sky130_fd_sc_hd__decap_3
XFILLER_85_489 VGND VGND VPWR VPWR sky130_fd_sc_hd__fill_2
Xhold1168 _7345_/Q VGND VGND VPWR VPWR _3994_/A0 sky130_fd_sc_hd__dlygate4sd3_1
Xhold1179 _7136_/Q VGND VGND VPWR VPWR _5394_/A0 sky130_fd_sc_hd__dlygate4sd3_1
XFILLER_53_320 VGND VGND VPWR VPWR sky130_fd_sc_hd__decap_3
XFILLER_54_38 VGND VGND VPWR VPWR sky130_fd_sc_hd__decap_3
XFILLER_26_578 VGND VGND VPWR VPWR sky130_fd_sc_hd__fill_2
XFILLER_80_150 VGND VGND VPWR VPWR sky130_fd_sc_hd__fill_1
XFILLER_81_673 VGND VGND VPWR VPWR sky130_fd_sc_hd__decap_3
XFILLER_13_217 VGND VGND VPWR VPWR sky130_fd_sc_hd__decap_3
XFILLER_13_228 VGND VGND VPWR VPWR sky130_fd_sc_hd__decap_3
X_6978_ _6978_/CLK _6978_/D VGND VGND VPWR VPWR _6978_/Q sky130_fd_sc_hd__dfxtp_2
XFILLER_110_55 VGND VGND VPWR VPWR sky130_fd_sc_hd__decap_3
XFILLER_41_559 VGND VGND VPWR VPWR sky130_fd_sc_hd__fill_1
XFILLER_21_261 VGND VGND VPWR VPWR sky130_fd_sc_hd__decap_3
XFILLER_107_322 VGND VGND VPWR VPWR sky130_fd_sc_hd__decap_3
XFILLER_5_438 VGND VGND VPWR VPWR sky130_fd_sc_hd__fill_1
XFILLER_107_355 VGND VGND VPWR VPWR sky130_fd_sc_hd__decap_3
XFILLER_102_3 VGND VGND VPWR VPWR sky130_fd_sc_hd__fill_2
XFILLER_107_388 VGND VGND VPWR VPWR sky130_fd_sc_hd__decap_3
XFILLER_79_57 VGND VGND VPWR VPWR sky130_fd_sc_hd__decap_3
XFILLER_0_110 VGND VGND VPWR VPWR sky130_fd_sc_hd__fill_2
Xhold991 _7383_/Q VGND VGND VPWR VPWR hold991/X sky130_fd_sc_hd__dlygate4sd3_1
Xhold980 _7053_/Q VGND VGND VPWR VPWR hold980/X sky130_fd_sc_hd__dlygate4sd3_1
XFILLER_76_401 VGND VGND VPWR VPWR sky130_fd_sc_hd__decap_3
XFILLER_88_250 VGND VGND VPWR VPWR sky130_fd_sc_hd__fill_2
XFILLER_95_12 VGND VGND VPWR VPWR sky130_fd_sc_hd__decap_3
XFILLER_103_594 VGND VGND VPWR VPWR sky130_fd_sc_hd__fill_2
XFILLER_48_125 VGND VGND VPWR VPWR sky130_fd_sc_hd__decap_3
XFILLER_28_50 VGND VGND VPWR VPWR sky130_fd_sc_hd__decap_3
XFILLER_36_309 VGND VGND VPWR VPWR sky130_fd_sc_hd__decap_3
XFILLER_48_158 VGND VGND VPWR VPWR sky130_fd_sc_hd__decap_3
XFILLER_95_89 VGND VGND VPWR VPWR sky130_fd_sc_hd__decap_3
XFILLER_17_501 VGND VGND VPWR VPWR sky130_fd_sc_hd__decap_3
XFILLER_28_72 VGND VGND VPWR VPWR sky130_fd_sc_hd__decap_3
XFILLER_57_681 VGND VGND VPWR VPWR sky130_fd_sc_hd__decap_3
XFILLER_76_489 VGND VGND VPWR VPWR sky130_fd_sc_hd__decap_3
XTAP_TAPCELL_ROW_47_816 VGND VPWR sky130_fd_sc_hd__tapvpwrvgnd_1
XFILLER_29_383 VGND VGND VPWR VPWR sky130_fd_sc_hd__decap_3
XFILLER_56_180 VGND VGND VPWR VPWR sky130_fd_sc_hd__decap_3
XFILLER_63_139 VGND VGND VPWR VPWR sky130_fd_sc_hd__decap_3
XFILLER_44_342 VGND VGND VPWR VPWR sky130_fd_sc_hd__decap_3
XTAP_TAPCELL_ROW_63_1007 VGND VPWR sky130_fd_sc_hd__tapvpwrvgnd_1
XFILLER_44_397 VGND VGND VPWR VPWR sky130_fd_sc_hd__decap_3
XFILLER_71_172 VGND VGND VPWR VPWR sky130_fd_sc_hd__decap_3
XTAP_TAPCELL_ROW_27_573 VGND VPWR sky130_fd_sc_hd__tapvpwrvgnd_1
XFILLER_44_82 VGND VGND VPWR VPWR sky130_fd_sc_hd__fill_2
XFILLER_12_283 VGND VGND VPWR VPWR sky130_fd_sc_hd__decap_3
XFILLER_8_232 VGND VGND VPWR VPWR sky130_fd_sc_hd__decap_3
XFILLER_60_70 VGND VGND VPWR VPWR sky130_fd_sc_hd__decap_3
XFILLER_8_265 VGND VGND VPWR VPWR sky130_fd_sc_hd__decap_3
XFILLER_5_21 VGND VGND VPWR VPWR sky130_fd_sc_hd__decap_3
XFILLER_8_298 VGND VGND VPWR VPWR sky130_fd_sc_hd__decap_3
Xoutput518 _5640_/Y VGND VGND VPWR VPWR instruction_out[4] sky130_fd_sc_hd__clkdlybuf4s25_1
Xoutput507 _3417_/C VGND VGND VPWR VPWR instruction_out[21] sky130_fd_sc_hd__clkdlybuf4s25_1
XFILLER_113_314 VGND VGND VPWR VPWR sky130_fd_sc_hd__decap_3
XFILLER_5_54 VGND VGND VPWR VPWR sky130_fd_sc_hd__fill_2
Xoutput529 _6991_/Q VGND VGND VPWR VPWR pc_out[14] sky130_fd_sc_hd__clkdlybuf4s25_1
XTAP_TAPCELL_ROW_74_1136 VGND VPWR sky130_fd_sc_hd__tapvpwrvgnd_1
XFILLER_99_526 VGND VGND VPWR VPWR sky130_fd_sc_hd__decap_3
XFILLER_5_87 VGND VGND VPWR VPWR sky130_fd_sc_hd__decap_3
X_4260_ _7262_/Q _4356_/A2 _3964_/S _7326_/Q VGND VGND VPWR VPWR _4264_/A sky130_fd_sc_hd__a22o_2
XFILLER_113_358 VGND VGND VPWR VPWR sky130_fd_sc_hd__decap_3
XFILLER_69_90 VGND VGND VPWR VPWR sky130_fd_sc_hd__decap_3
X_4191_ _7071_/Q _4265_/B _4205_/A VGND VGND VPWR VPWR _4637_/C sky130_fd_sc_hd__o21a_2
XFILLER_39_125 VGND VGND VPWR VPWR sky130_fd_sc_hd__decap_3
XFILLER_79_272 VGND VGND VPWR VPWR sky130_fd_sc_hd__decap_3
XFILLER_67_445 VGND VGND VPWR VPWR sky130_fd_sc_hd__decap_3
XFILLER_94_253 VGND VGND VPWR VPWR sky130_fd_sc_hd__decap_3
XFILLER_39_169 VGND VGND VPWR VPWR sky130_fd_sc_hd__decap_3
XFILLER_54_106 VGND VGND VPWR VPWR sky130_fd_sc_hd__decap_3
XFILLER_67_478 VGND VGND VPWR VPWR sky130_fd_sc_hd__decap_3
XFILLER_54_139 VGND VGND VPWR VPWR sky130_fd_sc_hd__fill_1
XFILLER_82_448 VGND VGND VPWR VPWR sky130_fd_sc_hd__decap_3
X_6901_ _6909_/CLK _6901_/D VGND VGND VPWR VPWR _6901_/Q sky130_fd_sc_hd__dfxtp_2
XFILLER_63_673 VGND VGND VPWR VPWR sky130_fd_sc_hd__decap_3
X_6832_ _6967_/CLK _6832_/D VGND VGND VPWR VPWR _6832_/Q sky130_fd_sc_hd__dfxtp_2
XFILLER_50_312 VGND VGND VPWR VPWR sky130_fd_sc_hd__decap_3
XFILLER_62_172 VGND VGND VPWR VPWR sky130_fd_sc_hd__decap_3
XFILLER_90_470 VGND VGND VPWR VPWR sky130_fd_sc_hd__decap_3
XTAP_TAPCELL_ROW_85_1276 VGND VPWR sky130_fd_sc_hd__tapvpwrvgnd_1
XFILLER_50_345 VGND VGND VPWR VPWR sky130_fd_sc_hd__decap_3
XFILLER_62_194 VGND VGND VPWR VPWR sky130_fd_sc_hd__fill_2
X_6763_ _6968_/CLK _6763_/D VGND VGND VPWR VPWR _6763_/Q sky130_fd_sc_hd__dfxtp_2
X_3975_ _7353_/Q _4517_/A0 _3996_/S VGND VGND VPWR VPWR _7353_/D sky130_fd_sc_hd__mux2_2
XFILLER_50_378 VGND VGND VPWR VPWR sky130_fd_sc_hd__decap_3
X_6694_ clkload1/A _6694_/D VGND VGND VPWR VPWR _6694_/Q sky130_fd_sc_hd__dfxtp_2
XFILLER_40_18 VGND VGND VPWR VPWR sky130_fd_sc_hd__decap_3
X_5645_ _6982_/Q _6979_/Q _3519_/B _5644_/X VGND VGND VPWR VPWR _5645_/X sky130_fd_sc_hd__o31a_2
XFILLER_40_29 VGND VGND VPWR VPWR sky130_fd_sc_hd__decap_3
X_5576_ hold954/X _5587_/B _5015_/X VGND VGND VPWR VPWR _7041_/D sky130_fd_sc_hd__a21o_2
XFILLER_116_141 VGND VGND VPWR VPWR sky130_fd_sc_hd__decap_3
X_7315_ clkload2/A _7315_/D _6595_/Y VGND VGND VPWR VPWR _7315_/Q sky130_fd_sc_hd__dfrtp_2
XFILLER_104_336 VGND VGND VPWR VPWR sky130_fd_sc_hd__decap_3
X_7246_ _7371_/CLK _7246_/D _6526_/Y VGND VGND VPWR VPWR _7246_/Q sky130_fd_sc_hd__dfrtp_2
X_4458_ _4458_/A _4039_/A VGND VGND VPWR VPWR _4458_/X sky130_fd_sc_hd__or2b_2
X_7177_ _7307_/CLK _7177_/D _6457_/Y VGND VGND VPWR VPWR _7177_/Q sky130_fd_sc_hd__dfrtp_2
X_3409_ _3449_/A _3449_/B _3421_/C _3409_/D VGND VGND VPWR VPWR _3409_/X sky130_fd_sc_hd__and4_2
XFILLER_112_380 VGND VGND VPWR VPWR sky130_fd_sc_hd__decap_3
XFILLER_58_412 VGND VGND VPWR VPWR sky130_fd_sc_hd__decap_3
X_4389_ _7081_/Q _4432_/A2 _4432_/B1 _4388_/X VGND VGND VPWR VPWR _4396_/A sky130_fd_sc_hd__o211ai_2
XFILLER_98_581 VGND VGND VPWR VPWR sky130_fd_sc_hd__decap_3
XFILLER_105_44 VGND VGND VPWR VPWR sky130_fd_sc_hd__decap_3
XFILLER_105_66 VGND VGND VPWR VPWR sky130_fd_sc_hd__decap_3
XFILLER_58_445 VGND VGND VPWR VPWR sky130_fd_sc_hd__decap_3
XFILLER_100_586 VGND VGND VPWR VPWR sky130_fd_sc_hd__fill_2
XFILLER_105_99 VGND VGND VPWR VPWR sky130_fd_sc_hd__fill_2
XFILLER_18_309 VGND VGND VPWR VPWR sky130_fd_sc_hd__decap_3
XFILLER_65_26 VGND VGND VPWR VPWR sky130_fd_sc_hd__decap_3
XFILLER_73_404 VGND VGND VPWR VPWR sky130_fd_sc_hd__decap_3
XFILLER_38_180 VGND VGND VPWR VPWR sky130_fd_sc_hd__decap_3
XFILLER_45_128 VGND VGND VPWR VPWR sky130_fd_sc_hd__decap_3
XFILLER_54_640 VGND VGND VPWR VPWR sky130_fd_sc_hd__decap_3
XFILLER_73_437 VGND VGND VPWR VPWR sky130_fd_sc_hd__decap_3
XFILLER_26_353 VGND VGND VPWR VPWR sky130_fd_sc_hd__decap_3
XFILLER_54_673 VGND VGND VPWR VPWR sky130_fd_sc_hd__fill_2
XFILLER_60_109 VGND VGND VPWR VPWR sky130_fd_sc_hd__decap_3
XFILLER_14_526 VGND VGND VPWR VPWR sky130_fd_sc_hd__decap_3
XFILLER_41_323 VGND VGND VPWR VPWR sky130_fd_sc_hd__fill_1
XFILLER_53_161 VGND VGND VPWR VPWR sky130_fd_sc_hd__decap_3
XFILLER_53_172 VGND VGND VPWR VPWR sky130_fd_sc_hd__decap_3
XFILLER_53_183 VGND VGND VPWR VPWR sky130_fd_sc_hd__decap_3
XFILLER_81_25 VGND VGND VPWR VPWR sky130_fd_sc_hd__decap_3
XFILLER_81_470 VGND VGND VPWR VPWR sky130_fd_sc_hd__decap_3
XFILLER_81_47 VGND VGND VPWR VPWR sky130_fd_sc_hd__decap_3
XFILLER_81_69 VGND VGND VPWR VPWR sky130_fd_sc_hd__decap_3
XTAP_TAPCELL_ROW_24_543 VGND VPWR sky130_fd_sc_hd__tapvpwrvgnd_1
XFILLER_14_41 VGND VGND VPWR VPWR sky130_fd_sc_hd__fill_2
XTAP_TAPCELL_ROW_52_874 VGND VPWR sky130_fd_sc_hd__tapvpwrvgnd_1
XFILLER_14_85 VGND VGND VPWR VPWR sky130_fd_sc_hd__decap_3
XFILLER_5_202 VGND VGND VPWR VPWR sky130_fd_sc_hd__decap_3
XFILLER_108_653 VGND VGND VPWR VPWR sky130_fd_sc_hd__decap_3
XFILLER_30_73 VGND VGND VPWR VPWR sky130_fd_sc_hd__fill_1
XFILLER_5_268 VGND VGND VPWR VPWR sky130_fd_sc_hd__decap_3
XFILLER_107_196 VGND VGND VPWR VPWR sky130_fd_sc_hd__decap_3
XFILLER_68_209 VGND VGND VPWR VPWR sky130_fd_sc_hd__decap_3
XFILLER_96_507 VGND VGND VPWR VPWR sky130_fd_sc_hd__decap_3
XFILLER_110_328 VGND VGND VPWR VPWR sky130_fd_sc_hd__decap_3
XFILLER_39_60 VGND VGND VPWR VPWR sky130_fd_sc_hd__decap_3
XFILLER_49_401 VGND VGND VPWR VPWR sky130_fd_sc_hd__decap_3
XFILLER_103_391 VGND VGND VPWR VPWR sky130_fd_sc_hd__fill_1
XFILLER_49_434 VGND VGND VPWR VPWR sky130_fd_sc_hd__decap_3
XFILLER_76_220 VGND VGND VPWR VPWR sky130_fd_sc_hd__decap_3
XFILLER_64_415 VGND VGND VPWR VPWR sky130_fd_sc_hd__decap_3
XFILLER_76_253 VGND VGND VPWR VPWR sky130_fd_sc_hd__fill_2
XFILLER_76_264 VGND VGND VPWR VPWR sky130_fd_sc_hd__decap_3
XFILLER_91_201 VGND VGND VPWR VPWR sky130_fd_sc_hd__decap_3
XFILLER_64_459 VGND VGND VPWR VPWR sky130_fd_sc_hd__decap_3
XFILLER_91_234 VGND VGND VPWR VPWR sky130_fd_sc_hd__decap_3
XFILLER_17_364 VGND VGND VPWR VPWR sky130_fd_sc_hd__decap_3
XFILLER_17_386 VGND VGND VPWR VPWR sky130_fd_sc_hd__decap_3
XFILLER_32_323 VGND VGND VPWR VPWR sky130_fd_sc_hd__decap_3
XFILLER_44_172 VGND VGND VPWR VPWR sky130_fd_sc_hd__decap_3
XFILLER_32_334 VGND VGND VPWR VPWR sky130_fd_sc_hd__decap_3
XFILLER_60_654 VGND VGND VPWR VPWR sky130_fd_sc_hd__decap_3
X_3760_ _6933_/Q _3859_/A2 _3863_/A2 _6707_/Q VGND VGND VPWR VPWR _3760_/X sky130_fd_sc_hd__a22o_2
XFILLER_71_91 VGND VGND VPWR VPWR sky130_fd_sc_hd__decap_3
X_3691_ _6941_/Q _3828_/A2 _3825_/B1 _6805_/Q VGND VGND VPWR VPWR _3691_/X sky130_fd_sc_hd__a22o_2
XFILLER_65_3 VGND VGND VPWR VPWR sky130_fd_sc_hd__decap_3
XFILLER_113_122 VGND VGND VPWR VPWR sky130_fd_sc_hd__decap_3
X_7100_ _7258_/CLK _7100_/D _6380_/Y VGND VGND VPWR VPWR _7100_/Q sky130_fd_sc_hd__dfrtp_2
X_5292_ hold993/X _4470_/X _5292_/S VGND VGND VPWR VPWR _7183_/D sky130_fd_sc_hd__mux2_2
X_4312_ _4394_/A _4337_/B _4311_/X VGND VGND VPWR VPWR _4313_/D sky130_fd_sc_hd__or3b_2
XFILLER_59_209 VGND VGND VPWR VPWR sky130_fd_sc_hd__fill_2
X_7031_ _7384_/CLK _7031_/D _6311_/Y VGND VGND VPWR VPWR _7031_/Q sky130_fd_sc_hd__dfrtp_2
X_4243_ _4620_/A _5032_/A VGND VGND VPWR VPWR _4243_/Y sky130_fd_sc_hd__nor2_2
XFILLER_99_367 VGND VGND VPWR VPWR sky130_fd_sc_hd__decap_3
XFILLER_67_231 VGND VGND VPWR VPWR sky130_fd_sc_hd__decap_3
X_4174_ _7296_/Q _4507_/S _4354_/B1 _7360_/Q VGND VGND VPWR VPWR _4174_/X sky130_fd_sc_hd__a22o_2
XFILLER_55_415 VGND VGND VPWR VPWR sky130_fd_sc_hd__decap_3
XFILLER_95_573 VGND VGND VPWR VPWR sky130_fd_sc_hd__decap_3
XFILLER_27_128 VGND VGND VPWR VPWR sky130_fd_sc_hd__decap_3
XFILLER_35_18 VGND VGND VPWR VPWR sky130_fd_sc_hd__decap_3
XFILLER_42_109 VGND VGND VPWR VPWR sky130_fd_sc_hd__decap_3
XFILLER_70_418 VGND VGND VPWR VPWR sky130_fd_sc_hd__fill_2
XFILLER_82_256 VGND VGND VPWR VPWR sky130_fd_sc_hd__decap_3
X_6815_ _6972_/CLK _6815_/D VGND VGND VPWR VPWR _6815_/Q sky130_fd_sc_hd__dfxtp_2
XFILLER_50_153 VGND VGND VPWR VPWR sky130_fd_sc_hd__decap_3
X_6746_ _6936_/CLK _6746_/D VGND VGND VPWR VPWR _6746_/Q sky130_fd_sc_hd__dfxtp_2
XTAP_TAPCELL_ROW_21_502 VGND VPWR sky130_fd_sc_hd__tapvpwrvgnd_1
XFILLER_50_186 VGND VGND VPWR VPWR sky130_fd_sc_hd__decap_3
XFILLER_50_197 VGND VGND VPWR VPWR sky130_fd_sc_hd__decap_3
X_3958_ _7361_/Q _4501_/A0 _3958_/S VGND VGND VPWR VPWR _7361_/D sky130_fd_sc_hd__mux2_2
X_6677_ _6684_/A VGND VGND VPWR VPWR _6677_/Y sky130_fd_sc_hd__inv_2
X_3889_ _6834_/Q _3889_/A2 _3889_/B1 _6829_/Q _3888_/X VGND VGND VPWR VPWR _3889_/X
+ sky130_fd_sc_hd__a221o_2
XTAP_TAPCELL_ROW_98_1423 VGND VPWR sky130_fd_sc_hd__tapvpwrvgnd_1
X_5628_ _5628_/A _5633_/B VGND VGND VPWR VPWR _7014_/D sky130_fd_sc_hd__or2_2
XFILLER_104_111 VGND VGND VPWR VPWR sky130_fd_sc_hd__decap_3
XFILLER_2_216 VGND VGND VPWR VPWR sky130_fd_sc_hd__decap_3
XFILLER_116_32 VGND VGND VPWR VPWR sky130_fd_sc_hd__decap_3
XFILLER_2_249 VGND VGND VPWR VPWR sky130_fd_sc_hd__decap_3
XFILLER_116_65 VGND VGND VPWR VPWR sky130_fd_sc_hd__decap_3
X_7229_ _7396_/CLK _7229_/D _6509_/Y VGND VGND VPWR VPWR _7229_/Q sky130_fd_sc_hd__dfrtp_2
XFILLER_58_242 VGND VGND VPWR VPWR sky130_fd_sc_hd__decap_3
XFILLER_76_47 VGND VGND VPWR VPWR sky130_fd_sc_hd__decap_3
XFILLER_58_253 VGND VGND VPWR VPWR sky130_fd_sc_hd__decap_3
XTAP_TAPCELL_ROW_29_602 VGND VPWR sky130_fd_sc_hd__tapvpwrvgnd_1
XFILLER_100_383 VGND VGND VPWR VPWR sky130_fd_sc_hd__decap_3
XFILLER_18_139 VGND VGND VPWR VPWR sky130_fd_sc_hd__fill_1
XFILLER_46_448 VGND VGND VPWR VPWR sky130_fd_sc_hd__fill_1
XFILLER_58_297 VGND VGND VPWR VPWR sky130_fd_sc_hd__decap_3
XFILLER_73_212 VGND VGND VPWR VPWR sky130_fd_sc_hd__decap_3
XFILLER_73_234 VGND VGND VPWR VPWR sky130_fd_sc_hd__decap_3
XFILLER_86_595 VGND VGND VPWR VPWR sky130_fd_sc_hd__fill_1
XTAP_TAPCELL_ROW_57_933 VGND VPWR sky130_fd_sc_hd__tapvpwrvgnd_1
XFILLER_73_278 VGND VGND VPWR VPWR sky130_fd_sc_hd__fill_2
XFILLER_92_35 VGND VGND VPWR VPWR sky130_fd_sc_hd__decap_3
XTAP_TAPCELL_ROW_1_260 VGND VPWR sky130_fd_sc_hd__tapvpwrvgnd_1
XTAP_TAPCELL_ROW_107_1541 VGND VPWR sky130_fd_sc_hd__tapvpwrvgnd_1
XTAP_TAPCELL_ROW_107_1530 VGND VPWR sky130_fd_sc_hd__tapvpwrvgnd_1
XFILLER_26_150 VGND VGND VPWR VPWR sky130_fd_sc_hd__decap_3
XFILLER_27_673 VGND VGND VPWR VPWR sky130_fd_sc_hd__fill_2
XFILLER_61_429 VGND VGND VPWR VPWR sky130_fd_sc_hd__decap_3
XFILLER_92_79 VGND VGND VPWR VPWR sky130_fd_sc_hd__decap_3
XFILLER_25_51 VGND VGND VPWR VPWR sky130_fd_sc_hd__decap_3
XFILLER_26_194 VGND VGND VPWR VPWR sky130_fd_sc_hd__fill_2
XFILLER_41_131 VGND VGND VPWR VPWR sky130_fd_sc_hd__decap_3
XFILLER_42_665 VGND VGND VPWR VPWR sky130_fd_sc_hd__fill_2
XTAP_TAPCELL_ROW_37_690 VGND VPWR sky130_fd_sc_hd__tapvpwrvgnd_1
XPHY_EDGE_ROW_1_Left_118 VGND VGND VPWR VPWR sky130_fd_sc_hd__decap_3
XFILLER_25_84 VGND VGND VPWR VPWR sky130_fd_sc_hd__decap_3
XFILLER_41_153 VGND VGND VPWR VPWR sky130_fd_sc_hd__decap_3
XFILLER_41_164 VGND VGND VPWR VPWR sky130_fd_sc_hd__decap_3
XFILLER_41_175 VGND VGND VPWR VPWR sky130_fd_sc_hd__decap_3
XFILLER_41_72 VGND VGND VPWR VPWR sky130_fd_sc_hd__decap_3
XFILLER_6_533 VGND VGND VPWR VPWR sky130_fd_sc_hd__decap_3
XFILLER_51_9 VGND VGND VPWR VPWR sky130_fd_sc_hd__decap_3
XTAP_TAPCELL_ROW_9_360 VGND VPWR sky130_fd_sc_hd__tapvpwrvgnd_1
XTAP_TAPCELL_ROW_71_1106 VGND VPWR sky130_fd_sc_hd__tapvpwrvgnd_1
XFILLER_111_615 VGND VGND VPWR VPWR sky130_fd_sc_hd__fill_1
XFILLER_69_529 VGND VGND VPWR VPWR sky130_fd_sc_hd__decap_3
XFILLER_96_304 VGND VGND VPWR VPWR sky130_fd_sc_hd__decap_3
XFILLER_96_315 VGND VGND VPWR VPWR sky130_fd_sc_hd__decap_3
XFILLER_1_293 VGND VGND VPWR VPWR sky130_fd_sc_hd__fill_1
XFILLER_2_11 VGND VGND VPWR VPWR sky130_fd_sc_hd__fill_1
XFILLER_49_231 VGND VGND VPWR VPWR sky130_fd_sc_hd__fill_1
XFILLER_77_551 VGND VGND VPWR VPWR sky130_fd_sc_hd__decap_3
XFILLER_96_348 VGND VGND VPWR VPWR sky130_fd_sc_hd__decap_3
XFILLER_2_55 VGND VGND VPWR VPWR sky130_fd_sc_hd__decap_3
XFILLER_49_253 VGND VGND VPWR VPWR sky130_fd_sc_hd__decap_3
XFILLER_49_275 VGND VGND VPWR VPWR sky130_fd_sc_hd__decap_3
XFILLER_92_510 VGND VGND VPWR VPWR sky130_fd_sc_hd__decap_3
XFILLER_64_234 VGND VGND VPWR VPWR sky130_fd_sc_hd__decap_3
XFILLER_77_595 VGND VGND VPWR VPWR sky130_fd_sc_hd__decap_3
XFILLER_18_640 VGND VGND VPWR VPWR sky130_fd_sc_hd__decap_3
XFILLER_18_662 VGND VGND VPWR VPWR sky130_fd_sc_hd__decap_3
XTAP_TAPCELL_ROW_69_1079 VGND VPWR sky130_fd_sc_hd__tapvpwrvgnd_1
XFILLER_17_150 VGND VGND VPWR VPWR sky130_fd_sc_hd__decap_3
XFILLER_45_470 VGND VGND VPWR VPWR sky130_fd_sc_hd__decap_3
XFILLER_52_418 VGND VGND VPWR VPWR sky130_fd_sc_hd__fill_2
XFILLER_92_598 VGND VGND VPWR VPWR sky130_fd_sc_hd__decap_3
X_4930_ _6995_/Q _4963_/A _6996_/Q VGND VGND VPWR VPWR _4931_/B sky130_fd_sc_hd__a21oi_2
X_4861_ _6998_/Q _6999_/Q _4912_/A _7000_/Q VGND VGND VPWR VPWR _4862_/B sky130_fd_sc_hd__a31o_2
XTAP_TAPCELL_ROW_82_1235 VGND VPWR sky130_fd_sc_hd__tapvpwrvgnd_1
XFILLER_20_304 VGND VGND VPWR VPWR sky130_fd_sc_hd__decap_3
XFILLER_60_451 VGND VGND VPWR VPWR sky130_fd_sc_hd__decap_3
X_6600_ _6600_/A VGND VGND VPWR VPWR _6600_/Y sky130_fd_sc_hd__inv_2
X_3812_ _3725_/X _3804_/X _3806_/X _3728_/Y _3811_/X VGND VGND VPWR VPWR _3812_/X
+ sky130_fd_sc_hd__a221o_2
XANTENNA_16 _5662_/C VGND VGND VPWR VPWR sky130_fd_sc_hd__diode_2
XANTENNA_27 _4650_/B VGND VGND VPWR VPWR sky130_fd_sc_hd__diode_2
XFILLER_20_348 VGND VGND VPWR VPWR sky130_fd_sc_hd__decap_3
XFILLER_60_495 VGND VGND VPWR VPWR sky130_fd_sc_hd__decap_3
X_4792_ _4997_/A1 _7004_/D _4777_/X _4791_/Y VGND VGND VPWR VPWR _4792_/X sky130_fd_sc_hd__a211o_2
X_6531_ _6532_/A VGND VGND VPWR VPWR _6531_/Y sky130_fd_sc_hd__inv_2
X_3743_ _6848_/Q _3890_/A2 _3651_/Y _6838_/Q _3742_/X VGND VGND VPWR VPWR _3743_/X
+ sky130_fd_sc_hd__a221o_2
X_6462_ _6462_/A VGND VGND VPWR VPWR _6462_/Y sky130_fd_sc_hd__inv_2
X_3674_ _6806_/Q VGND VGND VPWR VPWR _3674_/Y sky130_fd_sc_hd__inv_2
XFILLER_9_382 VGND VGND VPWR VPWR sky130_fd_sc_hd__fill_1
X_6393_ _6553_/A VGND VGND VPWR VPWR _6393_/Y sky130_fd_sc_hd__inv_2
X_5413_ _7127_/Q _5107_/X _5419_/S VGND VGND VPWR VPWR _7127_/D sky130_fd_sc_hd__mux2_2
X_5344_ _7159_/Q _5107_/X _5350_/S VGND VGND VPWR VPWR _7159_/D sky130_fd_sc_hd__mux2_2
XTAP_TAPCELL_ROW_93_1364 VGND VPWR sky130_fd_sc_hd__tapvpwrvgnd_1
XFILLER_102_615 VGND VGND VPWR VPWR sky130_fd_sc_hd__decap_3
XFILLER_102_626 VGND VGND VPWR VPWR sky130_fd_sc_hd__decap_3
XFILLER_114_475 VGND VGND VPWR VPWR sky130_fd_sc_hd__fill_1
XFILLER_87_326 VGND VGND VPWR VPWR sky130_fd_sc_hd__decap_3
XFILLER_102_648 VGND VGND VPWR VPWR sky130_fd_sc_hd__decap_3
XFILLER_87_337 VGND VGND VPWR VPWR sky130_fd_sc_hd__decap_3
X_7014_ _7258_/CLK _7014_/D _6294_/Y VGND VGND VPWR VPWR _7014_/Q sky130_fd_sc_hd__dfrtp_2
X_4226_ _4372_/A _4627_/A VGND VGND VPWR VPWR _4620_/A sky130_fd_sc_hd__nor2_2
XFILLER_101_169 VGND VGND VPWR VPWR sky130_fd_sc_hd__fill_1
XFILLER_28_415 VGND VGND VPWR VPWR sky130_fd_sc_hd__decap_3
XFILLER_68_551 VGND VGND VPWR VPWR sky130_fd_sc_hd__decap_3
XFILLER_68_584 VGND VGND VPWR VPWR sky130_fd_sc_hd__decap_3
X_4157_ _4157_/A _4205_/C VGND VGND VPWR VPWR _4158_/B sky130_fd_sc_hd__nand2_2
XFILLER_55_201 VGND VGND VPWR VPWR sky130_fd_sc_hd__decap_3
XFILLER_55_234 VGND VGND VPWR VPWR sky130_fd_sc_hd__decap_3
XFILLER_68_595 VGND VGND VPWR VPWR sky130_fd_sc_hd__decap_3
XFILLER_83_532 VGND VGND VPWR VPWR sky130_fd_sc_hd__fill_2
XFILLER_95_381 VGND VGND VPWR VPWR sky130_fd_sc_hd__decap_3
XFILLER_83_576 VGND VGND VPWR VPWR sky130_fd_sc_hd__decap_3
X_4088_ _7238_/Q _4414_/A2 _4505_/S _7051_/Q VGND VGND VPWR VPWR _4088_/X sky130_fd_sc_hd__a22o_2
XTAP_TAPCELL_ROW_54_903 VGND VPWR sky130_fd_sc_hd__tapvpwrvgnd_1
XFILLER_15_109 VGND VGND VPWR VPWR sky130_fd_sc_hd__decap_3
XFILLER_70_226 VGND VGND VPWR VPWR sky130_fd_sc_hd__decap_3
XFILLER_24_643 VGND VGND VPWR VPWR sky130_fd_sc_hd__fill_1
XFILLER_24_654 VGND VGND VPWR VPWR sky130_fd_sc_hd__fill_1
XFILLER_62_27 VGND VGND VPWR VPWR sky130_fd_sc_hd__fill_1
XFILLER_70_259 VGND VGND VPWR VPWR sky130_fd_sc_hd__decap_3
XFILLER_51_473 VGND VGND VPWR VPWR sky130_fd_sc_hd__decap_3
XFILLER_62_38 VGND VGND VPWR VPWR sky130_fd_sc_hd__decap_3
XFILLER_62_49 VGND VGND VPWR VPWR sky130_fd_sc_hd__decap_3
XTAP_TAPCELL_ROW_34_660 VGND VPWR sky130_fd_sc_hd__tapvpwrvgnd_1
XFILLER_11_337 VGND VGND VPWR VPWR sky130_fd_sc_hd__decap_3
XFILLER_23_175 VGND VGND VPWR VPWR sky130_fd_sc_hd__decap_3
XTAP_TAPCELL_ROW_62_991 VGND VPWR sky130_fd_sc_hd__tapvpwrvgnd_1
XTAP_TAPCELL_ROW_102_1471 VGND VPWR sky130_fd_sc_hd__tapvpwrvgnd_1
XFILLER_109_203 VGND VGND VPWR VPWR sky130_fd_sc_hd__decap_3
XFILLER_7_308 VGND VGND VPWR VPWR sky130_fd_sc_hd__decap_3
X_6729_ _6909_/CLK _6729_/D VGND VGND VPWR VPWR _6729_/Q sky130_fd_sc_hd__dfxtp_2
XFILLER_109_258 VGND VGND VPWR VPWR sky130_fd_sc_hd__decap_3
XFILLER_11_20 VGND VGND VPWR VPWR sky130_fd_sc_hd__fill_2
XFILLER_3_558 VGND VGND VPWR VPWR sky130_fd_sc_hd__fill_2
XFILLER_87_24 VGND VGND VPWR VPWR sky130_fd_sc_hd__decap_3
XFILLER_105_464 VGND VGND VPWR VPWR sky130_fd_sc_hd__decap_3
XFILLER_78_315 VGND VGND VPWR VPWR sky130_fd_sc_hd__decap_3
XFILLER_87_57 VGND VGND VPWR VPWR sky130_fd_sc_hd__decap_3
XFILLER_87_68 VGND VGND VPWR VPWR sky130_fd_sc_hd__decap_3
XFILLER_59_551 VGND VGND VPWR VPWR sky130_fd_sc_hd__fill_1
XFILLER_93_307 VGND VGND VPWR VPWR sky130_fd_sc_hd__decap_3
XFILLER_19_426 VGND VGND VPWR VPWR sky130_fd_sc_hd__decap_3
XFILLER_46_212 VGND VGND VPWR VPWR sky130_fd_sc_hd__decap_3
XFILLER_86_392 VGND VGND VPWR VPWR sky130_fd_sc_hd__decap_3
XFILLER_46_256 VGND VGND VPWR VPWR sky130_fd_sc_hd__decap_3
XFILLER_74_554 VGND VGND VPWR VPWR sky130_fd_sc_hd__decap_3
XFILLER_74_587 VGND VGND VPWR VPWR sky130_fd_sc_hd__fill_1
XFILLER_74_598 VGND VGND VPWR VPWR sky130_fd_sc_hd__decap_3
XFILLER_36_94 VGND VGND VPWR VPWR sky130_fd_sc_hd__fill_1
XFILLER_61_237 VGND VGND VPWR VPWR sky130_fd_sc_hd__fill_2
XFILLER_61_259 VGND VGND VPWR VPWR sky130_fd_sc_hd__decap_3
XFILLER_42_451 VGND VGND VPWR VPWR sky130_fd_sc_hd__decap_3
XFILLER_14_197 VGND VGND VPWR VPWR sky130_fd_sc_hd__decap_3
XFILLER_52_71 VGND VGND VPWR VPWR sky130_fd_sc_hd__decap_3
XFILLER_6_341 VGND VGND VPWR VPWR sky130_fd_sc_hd__decap_3
Xhold809 _6849_/Q VGND VGND VPWR VPWR _6849_/D sky130_fd_sc_hd__dlygate4sd3_1
XTAP_TAPCELL_ROW_12_398 VGND VPWR sky130_fd_sc_hd__tapvpwrvgnd_1
XFILLER_115_228 VGND VGND VPWR VPWR sky130_fd_sc_hd__decap_3
X_3390_ _7155_/Q _4339_/B1 _3379_/X _3389_/X VGND VGND VPWR VPWR _3390_/X sky130_fd_sc_hd__a211o_2
XFILLER_96_112 VGND VGND VPWR VPWR sky130_fd_sc_hd__decap_3
XFILLER_97_635 VGND VGND VPWR VPWR sky130_fd_sc_hd__decap_3
XFILLER_69_348 VGND VGND VPWR VPWR sky130_fd_sc_hd__fill_2
X_5060_ _5577_/S _5045_/X _5059_/X _4467_/B VGND VGND VPWR VPWR _5060_/X sky130_fd_sc_hd__a22o_2
XFILLER_97_668 VGND VGND VPWR VPWR sky130_fd_sc_hd__decap_3
XFILLER_28_3 VGND VGND VPWR VPWR sky130_fd_sc_hd__decap_3
XFILLER_96_156 VGND VGND VPWR VPWR sky130_fd_sc_hd__decap_3
X_4011_ _7342_/Q _3947_/S _4399_/A2 _7374_/Q _4429_/C1 VGND VGND VPWR VPWR _4011_/X
+ sky130_fd_sc_hd__a221o_2
XFILLER_37_212 VGND VGND VPWR VPWR sky130_fd_sc_hd__decap_3
XFILLER_77_370 VGND VGND VPWR VPWR sky130_fd_sc_hd__decap_3
XFILLER_84_329 VGND VGND VPWR VPWR sky130_fd_sc_hd__decap_3
XFILLER_96_189 VGND VGND VPWR VPWR sky130_fd_sc_hd__decap_3
XFILLER_37_234 VGND VGND VPWR VPWR sky130_fd_sc_hd__decap_3
XFILLER_65_543 VGND VGND VPWR VPWR sky130_fd_sc_hd__fill_1
XFILLER_37_278 VGND VGND VPWR VPWR sky130_fd_sc_hd__fill_2
XFILLER_80_513 VGND VGND VPWR VPWR sky130_fd_sc_hd__decap_3
XFILLER_52_259 VGND VGND VPWR VPWR sky130_fd_sc_hd__decap_3
XFILLER_92_395 VGND VGND VPWR VPWR sky130_fd_sc_hd__decap_3
X_4913_ _4913_/A1 _3762_/X _4910_/Y _6997_/D _4836_/S VGND VGND VPWR VPWR _4913_/X
+ sky130_fd_sc_hd__o32a_2
XFILLER_33_484 VGND VGND VPWR VPWR sky130_fd_sc_hd__fill_1
XFILLER_60_292 VGND VGND VPWR VPWR sky130_fd_sc_hd__decap_3
X_4844_ _4633_/A _4111_/B _4842_/X _4843_/Y _4948_/A VGND VGND VPWR VPWR _4855_/A
+ sky130_fd_sc_hd__a311oi_2
X_4775_ _4775_/A _4775_/B VGND VGND VPWR VPWR _7004_/D sky130_fd_sc_hd__nor2_2
X_6514_ _6578_/A VGND VGND VPWR VPWR _6514_/Y sky130_fd_sc_hd__inv_2
X_3726_ _3714_/X _3721_/X _3724_/X _3725_/X VGND VGND VPWR VPWR _3726_/X sky130_fd_sc_hd__a22o_2
XFILLER_106_206 VGND VGND VPWR VPWR sky130_fd_sc_hd__decap_3
XFILLER_9_190 VGND VGND VPWR VPWR sky130_fd_sc_hd__decap_3
XFILLER_106_228 VGND VGND VPWR VPWR sky130_fd_sc_hd__decap_3
X_6445_ _6604_/A VGND VGND VPWR VPWR _6445_/Y sky130_fd_sc_hd__inv_2
X_6376_ _6568_/A VGND VGND VPWR VPWR _6376_/Y sky130_fd_sc_hd__inv_2
X_5327_ _5327_/A0 _4978_/X _5327_/S VGND VGND VPWR VPWR _7167_/D sky130_fd_sc_hd__mux2_2
XFILLER_87_123 VGND VGND VPWR VPWR sky130_fd_sc_hd__decap_3
XFILLER_88_668 VGND VGND VPWR VPWR sky130_fd_sc_hd__decap_3
XFILLER_102_467 VGND VGND VPWR VPWR sky130_fd_sc_hd__decap_3
XFILLER_57_27 VGND VGND VPWR VPWR sky130_fd_sc_hd__decap_3
XFILLER_87_156 VGND VGND VPWR VPWR sky130_fd_sc_hd__decap_3
X_5258_ _5258_/A0 _4945_/X _5262_/S VGND VGND VPWR VPWR _7201_/D sky130_fd_sc_hd__mux2_2
XFILLER_113_11 VGND VGND VPWR VPWR sky130_fd_sc_hd__decap_3
XFILLER_28_212 VGND VGND VPWR VPWR sky130_fd_sc_hd__decap_3
XFILLER_56_510 VGND VGND VPWR VPWR sky130_fd_sc_hd__decap_3
XFILLER_68_392 VGND VGND VPWR VPWR sky130_fd_sc_hd__decap_3
X_4209_ _4633_/A _4903_/A _4845_/A _4890_/B VGND VGND VPWR VPWR _4384_/A sky130_fd_sc_hd__and4_2
XFILLER_28_234 VGND VGND VPWR VPWR sky130_fd_sc_hd__fill_2
XFILLER_28_256 VGND VGND VPWR VPWR sky130_fd_sc_hd__decap_3
XFILLER_83_340 VGND VGND VPWR VPWR sky130_fd_sc_hd__decap_3
XFILLER_113_66 VGND VGND VPWR VPWR sky130_fd_sc_hd__fill_1
XFILLER_16_407 VGND VGND VPWR VPWR sky130_fd_sc_hd__decap_3
XFILLER_56_587 VGND VGND VPWR VPWR sky130_fd_sc_hd__fill_1
XFILLER_71_502 VGND VGND VPWR VPWR sky130_fd_sc_hd__fill_2
XFILLER_73_37 VGND VGND VPWR VPWR sky130_fd_sc_hd__decap_3
XFILLER_83_373 VGND VGND VPWR VPWR sky130_fd_sc_hd__decap_3
XTAP_TAPCELL_ROW_104_1500 VGND VPWR sky130_fd_sc_hd__tapvpwrvgnd_1
XFILLER_113_99 VGND VGND VPWR VPWR sky130_fd_sc_hd__decap_3
XFILLER_43_248 VGND VGND VPWR VPWR sky130_fd_sc_hd__decap_3
XFILLER_71_546 VGND VGND VPWR VPWR sky130_fd_sc_hd__decap_3
XFILLER_71_579 VGND VGND VPWR VPWR sky130_fd_sc_hd__decap_3
XFILLER_51_281 VGND VGND VPWR VPWR sky130_fd_sc_hd__decap_3
XFILLER_11_134 VGND VGND VPWR VPWR sky130_fd_sc_hd__decap_3
XPHY_EDGE_ROW_91_Left_208 VGND VGND VPWR VPWR sky130_fd_sc_hd__decap_3
XFILLER_11_167 VGND VGND VPWR VPWR sky130_fd_sc_hd__fill_1
XFILLER_11_178 VGND VGND VPWR VPWR sky130_fd_sc_hd__fill_1
XFILLER_22_41 VGND VGND VPWR VPWR sky130_fd_sc_hd__decap_3
XFILLER_20_690 VGND VGND VPWR VPWR sky130_fd_sc_hd__fill_2
XFILLER_22_74 VGND VGND VPWR VPWR sky130_fd_sc_hd__decap_3
XFILLER_22_85 VGND VGND VPWR VPWR sky130_fd_sc_hd__decap_3
XFILLER_3_333 VGND VGND VPWR VPWR sky130_fd_sc_hd__decap_3
XFILLER_98_45 VGND VGND VPWR VPWR sky130_fd_sc_hd__decap_3
XFILLER_112_209 VGND VGND VPWR VPWR sky130_fd_sc_hd__decap_3
XFILLER_3_366 VGND VGND VPWR VPWR sky130_fd_sc_hd__decap_3
XFILLER_79_613 VGND VGND VPWR VPWR sky130_fd_sc_hd__decap_3
XFILLER_98_78 VGND VGND VPWR VPWR sky130_fd_sc_hd__fill_1
XFILLER_105_272 VGND VGND VPWR VPWR sky130_fd_sc_hd__decap_3
XFILLER_3_399 VGND VGND VPWR VPWR sky130_fd_sc_hd__decap_3
XFILLER_78_112 VGND VGND VPWR VPWR sky130_fd_sc_hd__fill_2
XFILLER_79_635 VGND VGND VPWR VPWR sky130_fd_sc_hd__decap_3
XFILLER_79_668 VGND VGND VPWR VPWR sky130_fd_sc_hd__fill_1
XFILLER_66_307 VGND VGND VPWR VPWR sky130_fd_sc_hd__fill_1
XFILLER_78_167 VGND VGND VPWR VPWR sky130_fd_sc_hd__decap_3
XFILLER_94_627 VGND VGND VPWR VPWR sky130_fd_sc_hd__decap_3
XFILLER_66_329 VGND VGND VPWR VPWR sky130_fd_sc_hd__decap_3
XFILLER_19_234 VGND VGND VPWR VPWR sky130_fd_sc_hd__decap_3
XFILLER_47_71 VGND VGND VPWR VPWR sky130_fd_sc_hd__decap_3
XFILLER_74_362 VGND VGND VPWR VPWR sky130_fd_sc_hd__fill_2
XFILLER_34_226 VGND VGND VPWR VPWR sky130_fd_sc_hd__decap_3
XTAP_TAPCELL_ROW_66_1049 VGND VPWR sky130_fd_sc_hd__tapvpwrvgnd_1
XTAP_TAPCELL_ROW_66_1038 VGND VPWR sky130_fd_sc_hd__tapvpwrvgnd_1
XFILLER_34_259 VGND VGND VPWR VPWR sky130_fd_sc_hd__decap_3
XFILLER_62_568 VGND VGND VPWR VPWR sky130_fd_sc_hd__fill_2
XFILLER_62_579 VGND VGND VPWR VPWR sky130_fd_sc_hd__decap_3
XTAP_TAPCELL_ROW_45_788 VGND VPWR sky130_fd_sc_hd__tapvpwrvgnd_1
XTAP_TAPCELL_ROW_17_457 VGND VPWR sky130_fd_sc_hd__tapvpwrvgnd_1
XFILLER_30_421 VGND VGND VPWR VPWR sky130_fd_sc_hd__decap_3
XFILLER_42_281 VGND VGND VPWR VPWR sky130_fd_sc_hd__decap_3
XFILLER_97_6 VGND VGND VPWR VPWR sky130_fd_sc_hd__decap_3
XFILLER_8_32 VGND VGND VPWR VPWR sky130_fd_sc_hd__decap_3
XFILLER_30_498 VGND VGND VPWR VPWR sky130_fd_sc_hd__decap_3
XFILLER_8_65 VGND VGND VPWR VPWR sky130_fd_sc_hd__decap_3
XFILLER_11_690 VGND VGND VPWR VPWR sky130_fd_sc_hd__fill_2
XFILLER_7_683 VGND VGND VPWR VPWR sky130_fd_sc_hd__fill_1
Xhold606 _6729_/Q VGND VGND VPWR VPWR _6729_/D sky130_fd_sc_hd__dlygate4sd3_1
Xhold617 _6891_/Q VGND VGND VPWR VPWR _6891_/D sky130_fd_sc_hd__dlygate4sd3_1
Xwire570 _3475_/Y VGND VGND VPWR VPWR _3502_/A sky130_fd_sc_hd__clkbuf_2
X_4491_ _4491_/A0 _7302_/Q _4491_/S VGND VGND VPWR VPWR _7334_/D sky130_fd_sc_hd__mux2_2
XFILLER_116_548 VGND VGND VPWR VPWR sky130_fd_sc_hd__decap_3
XFILLER_6_193 VGND VGND VPWR VPWR sky130_fd_sc_hd__decap_3
Xhold628 _6858_/Q VGND VGND VPWR VPWR _6858_/D sky130_fd_sc_hd__dlygate4sd3_1
Xhold639 _6719_/Q VGND VGND VPWR VPWR _6719_/D sky130_fd_sc_hd__dlygate4sd3_1
X_3442_ _3442_/A _3442_/B VGND VGND VPWR VPWR _4394_/A sky130_fd_sc_hd__nand2_2
XTAP_TAPCELL_ROW_77_1178 VGND VPWR sky130_fd_sc_hd__tapvpwrvgnd_1
X_3373_ _3560_/B _3370_/Y _3399_/A VGND VGND VPWR VPWR _3429_/A sky130_fd_sc_hd__a21o_2
XFILLER_69_134 VGND VGND VPWR VPWR sky130_fd_sc_hd__fill_2
XFILLER_97_432 VGND VGND VPWR VPWR sky130_fd_sc_hd__fill_1
X_5112_ _4292_/A _3594_/B _4295_/X VGND VGND VPWR VPWR _5113_/B sky130_fd_sc_hd__a21oi_2
XTAP_TAPCELL_ROW_90_1334 VGND VPWR sky130_fd_sc_hd__tapvpwrvgnd_1
XFILLER_111_231 VGND VGND VPWR VPWR sky130_fd_sc_hd__decap_3
XFILLER_111_253 VGND VGND VPWR VPWR sky130_fd_sc_hd__decap_3
XFILLER_97_476 VGND VGND VPWR VPWR sky130_fd_sc_hd__decap_3
XFILLER_38_510 VGND VGND VPWR VPWR sky130_fd_sc_hd__fill_1
XFILLER_57_329 VGND VGND VPWR VPWR sky130_fd_sc_hd__decap_3
XFILLER_69_178 VGND VGND VPWR VPWR sky130_fd_sc_hd__decap_3
XFILLER_78_690 VGND VGND VPWR VPWR sky130_fd_sc_hd__fill_2
XFILLER_84_115 VGND VGND VPWR VPWR sky130_fd_sc_hd__decap_3
XFILLER_85_649 VGND VGND VPWR VPWR sky130_fd_sc_hd__decap_3
X_5043_ _6988_/Q _5066_/A VGND VGND VPWR VPWR _5044_/B sky130_fd_sc_hd__nor2_2
XFILLER_65_340 VGND VGND VPWR VPWR sky130_fd_sc_hd__decap_3
XFILLER_38_587 VGND VGND VPWR VPWR sky130_fd_sc_hd__fill_1
XFILLER_53_502 VGND VGND VPWR VPWR sky130_fd_sc_hd__fill_2
XFILLER_65_373 VGND VGND VPWR VPWR sky130_fd_sc_hd__decap_3
XFILLER_25_248 VGND VGND VPWR VPWR sky130_fd_sc_hd__decap_3
XFILLER_53_546 VGND VGND VPWR VPWR sky130_fd_sc_hd__fill_2
XFILLER_92_170 VGND VGND VPWR VPWR sky130_fd_sc_hd__decap_3
X_6994_ _7338_/CLK _6994_/D _6274_/Y VGND VGND VPWR VPWR _6994_/Q sky130_fd_sc_hd__dfrtp_2
XFILLER_43_29 VGND VGND VPWR VPWR sky130_fd_sc_hd__decap_3
XFILLER_80_365 VGND VGND VPWR VPWR sky130_fd_sc_hd__decap_3
XFILLER_33_281 VGND VGND VPWR VPWR sky130_fd_sc_hd__decap_3
XFILLER_40_229 VGND VGND VPWR VPWR sky130_fd_sc_hd__decap_3
X_4827_ _4827_/A _4827_/B VGND VGND VPWR VPWR _4827_/X sky130_fd_sc_hd__xor2_2
X_4758_ _7004_/Q _4804_/A VGND VGND VPWR VPWR _4777_/B sky130_fd_sc_hd__nand2_2
XFILLER_107_537 VGND VGND VPWR VPWR sky130_fd_sc_hd__decap_3
X_4689_ _7002_/Q _4834_/A _4688_/X _7003_/Q VGND VGND VPWR VPWR _4804_/A sky130_fd_sc_hd__o211a_2
X_3709_ _3629_/A _3708_/X _3753_/B1 VGND VGND VPWR VPWR _3709_/X sky130_fd_sc_hd__a21o_2
XFILLER_108_44 VGND VGND VPWR VPWR sky130_fd_sc_hd__fill_2
X_6428_ _6558_/A VGND VGND VPWR VPWR _6428_/Y sky130_fd_sc_hd__inv_2
XFILLER_108_66 VGND VGND VPWR VPWR sky130_fd_sc_hd__fill_1
XFILLER_108_77 VGND VGND VPWR VPWR sky130_fd_sc_hd__decap_3
XFILLER_88_410 VGND VGND VPWR VPWR sky130_fd_sc_hd__decap_3
XFILLER_102_220 VGND VGND VPWR VPWR sky130_fd_sc_hd__decap_3
XFILLER_108_88 VGND VGND VPWR VPWR sky130_fd_sc_hd__decap_3
XFILLER_68_59 VGND VGND VPWR VPWR sky130_fd_sc_hd__decap_3
X_6359_ _6385_/A VGND VGND VPWR VPWR _6359_/Y sky130_fd_sc_hd__inv_2
XFILLER_102_253 VGND VGND VPWR VPWR sky130_fd_sc_hd__decap_3
XFILLER_102_297 VGND VGND VPWR VPWR sky130_fd_sc_hd__decap_3
XFILLER_48_318 VGND VGND VPWR VPWR sky130_fd_sc_hd__decap_3
XFILLER_88_498 VGND VGND VPWR VPWR sky130_fd_sc_hd__fill_2
XTAP_TAPCELL_ROW_110_1570 VGND VPWR sky130_fd_sc_hd__tapvpwrvgnd_1
XFILLER_29_543 VGND VGND VPWR VPWR sky130_fd_sc_hd__fill_2
XFILLER_75_148 VGND VGND VPWR VPWR sky130_fd_sc_hd__decap_3
XFILLER_16_215 VGND VGND VPWR VPWR sky130_fd_sc_hd__decap_3
XFILLER_29_598 VGND VGND VPWR VPWR sky130_fd_sc_hd__fill_1
XFILLER_56_351 VGND VGND VPWR VPWR sky130_fd_sc_hd__decap_3
XFILLER_84_660 VGND VGND VPWR VPWR sky130_fd_sc_hd__decap_3
XFILLER_90_118 VGND VGND VPWR VPWR sky130_fd_sc_hd__decap_3
XFILLER_16_248 VGND VGND VPWR VPWR sky130_fd_sc_hd__decap_3
XFILLER_17_63 VGND VGND VPWR VPWR sky130_fd_sc_hd__fill_2
XFILLER_16_259 VGND VGND VPWR VPWR sky130_fd_sc_hd__decap_3
XFILLER_17_85 VGND VGND VPWR VPWR sky130_fd_sc_hd__decap_3
XFILLER_12_410 VGND VGND VPWR VPWR sky130_fd_sc_hd__decap_3
XFILLER_24_281 VGND VGND VPWR VPWR sky130_fd_sc_hd__fill_2
XFILLER_31_218 VGND VGND VPWR VPWR sky130_fd_sc_hd__decap_3
XTAP_TAPCELL_ROW_14_416 VGND VPWR sky130_fd_sc_hd__tapvpwrvgnd_1
XFILLER_12_454 VGND VGND VPWR VPWR sky130_fd_sc_hd__decap_3
XFILLER_33_51 VGND VGND VPWR VPWR sky130_fd_sc_hd__decap_3
XTAP_TAPCELL_ROW_42_758 VGND VPWR sky130_fd_sc_hd__tapvpwrvgnd_1
XFILLER_3_163 VGND VGND VPWR VPWR sky130_fd_sc_hd__decap_3
XFILLER_4_675 VGND VGND VPWR VPWR sky130_fd_sc_hd__fill_1
XFILLER_98_207 VGND VGND VPWR VPWR sky130_fd_sc_hd__fill_2
XFILLER_106_592 VGND VGND VPWR VPWR sky130_fd_sc_hd__decap_3
XFILLER_79_432 VGND VGND VPWR VPWR sky130_fd_sc_hd__decap_3
XFILLER_79_476 VGND VGND VPWR VPWR sky130_fd_sc_hd__decap_3
XFILLER_12_6 VGND VGND VPWR VPWR sky130_fd_sc_hd__decap_3
XFILLER_47_340 VGND VGND VPWR VPWR sky130_fd_sc_hd__decap_3
XFILLER_66_137 VGND VGND VPWR VPWR sky130_fd_sc_hd__decap_3
XFILLER_66_159 VGND VGND VPWR VPWR sky130_fd_sc_hd__decap_3
XFILLER_81_107 VGND VGND VPWR VPWR sky130_fd_sc_hd__decap_3
XFILLER_62_332 VGND VGND VPWR VPWR sky130_fd_sc_hd__decap_3
XFILLER_74_192 VGND VGND VPWR VPWR sky130_fd_sc_hd__decap_3
XFILLER_74_80 VGND VGND VPWR VPWR sky130_fd_sc_hd__decap_3
X_3991_ _5151_/A _3991_/B VGND VGND VPWR VPWR _3991_/X sky130_fd_sc_hd__or2_2
XFILLER_15_270 VGND VGND VPWR VPWR sky130_fd_sc_hd__fill_2
XFILLER_22_218 VGND VGND VPWR VPWR sky130_fd_sc_hd__decap_3
XFILLER_95_3 VGND VGND VPWR VPWR sky130_fd_sc_hd__decap_3
XFILLER_15_281 VGND VGND VPWR VPWR sky130_fd_sc_hd__decap_3
XFILLER_30_240 VGND VGND VPWR VPWR sky130_fd_sc_hd__decap_3
XFILLER_30_262 VGND VGND VPWR VPWR sky130_fd_sc_hd__decap_3
X_7400_ _7403_/CLK _7400_/D _6680_/Y VGND VGND VPWR VPWR _7400_/Q sky130_fd_sc_hd__dfrtp_2
X_5661_ _5661_/A _5661_/B _5661_/C _5661_/D VGND VGND VPWR VPWR _5661_/X sky130_fd_sc_hd__and4_2
XFILLER_30_295 VGND VGND VPWR VPWR sky130_fd_sc_hd__decap_3
X_4612_ _4612_/A _4612_/B VGND VGND VPWR VPWR _5114_/B sky130_fd_sc_hd__nor2_2
XFILLER_116_301 VGND VGND VPWR VPWR sky130_fd_sc_hd__decap_3
X_7331_ _7363_/CLK _7331_/D _6611_/Y VGND VGND VPWR VPWR _7331_/Q sky130_fd_sc_hd__dfrtp_2
XFILLER_116_356 VGND VGND VPWR VPWR sky130_fd_sc_hd__decap_3
X_7262_ _7359_/CLK _7262_/D _6542_/Y VGND VGND VPWR VPWR _7262_/Q sky130_fd_sc_hd__dfrtp_2
XFILLER_104_529 VGND VGND VPWR VPWR sky130_fd_sc_hd__decap_3
X_4474_ _4474_/A0 _7310_/Q _4491_/S VGND VGND VPWR VPWR _4474_/X sky130_fd_sc_hd__mux2_2
X_7193_ _7394_/CLK _7193_/D _6473_/Y VGND VGND VPWR VPWR _7193_/Q sky130_fd_sc_hd__dfrtp_2
X_3425_ _3589_/A _3591_/A _3589_/B _3590_/C VGND VGND VPWR VPWR _3527_/A sky130_fd_sc_hd__o31a_2
XFILLER_38_18 VGND VGND VPWR VPWR sky130_fd_sc_hd__decap_3
XFILLER_58_616 VGND VGND VPWR VPWR sky130_fd_sc_hd__fill_2
XFILLER_85_402 VGND VGND VPWR VPWR sky130_fd_sc_hd__decap_3
XFILLER_97_240 VGND VGND VPWR VPWR sky130_fd_sc_hd__decap_3
X_3356_ _5118_/D _3354_/X _3355_/Y _3561_/A VGND VGND VPWR VPWR _4537_/B sky130_fd_sc_hd__a22o_2
XFILLER_112_584 VGND VGND VPWR VPWR sky130_fd_sc_hd__decap_3
XFILLER_112_595 VGND VGND VPWR VPWR sky130_fd_sc_hd__decap_3
XFILLER_38_29 VGND VGND VPWR VPWR sky130_fd_sc_hd__decap_3
XFILLER_85_435 VGND VGND VPWR VPWR sky130_fd_sc_hd__decap_3
XFILLER_97_284 VGND VGND VPWR VPWR sky130_fd_sc_hd__decap_3
Xhold1103 _3983_/X VGND VGND VPWR VPWR _7349_/D sky130_fd_sc_hd__dlygate4sd3_1
Xhold1114 _7333_/Q VGND VGND VPWR VPWR _4493_/A0 sky130_fd_sc_hd__dlygate4sd3_1
XFILLER_57_137 VGND VGND VPWR VPWR sky130_fd_sc_hd__decap_3
XFILLER_57_159 VGND VGND VPWR VPWR sky130_fd_sc_hd__decap_3
Xhold1125 _7178_/Q VGND VGND VPWR VPWR _5304_/A0 sky130_fd_sc_hd__dlygate4sd3_1
Xhold1136 _7132_/Q VGND VGND VPWR VPWR _5402_/A0 sky130_fd_sc_hd__dlygate4sd3_1
Xhold1147 _7249_/Q VGND VGND VPWR VPWR _5142_/A0 sky130_fd_sc_hd__dlygate4sd3_1
Xhold1158 _7299_/Q VGND VGND VPWR VPWR _4563_/A sky130_fd_sc_hd__dlygate4sd3_1
X_5026_ _5026_/A _5026_/B VGND VGND VPWR VPWR _6990_/D sky130_fd_sc_hd__nor2_2
Xhold1169 _7150_/Q VGND VGND VPWR VPWR _5365_/A0 sky130_fd_sc_hd__dlygate4sd3_1
XFILLER_53_332 VGND VGND VPWR VPWR sky130_fd_sc_hd__decap_3
XFILLER_65_181 VGND VGND VPWR VPWR sky130_fd_sc_hd__decap_3
XFILLER_93_490 VGND VGND VPWR VPWR sky130_fd_sc_hd__decap_3
XFILLER_26_568 VGND VGND VPWR VPWR sky130_fd_sc_hd__decap_3
XFILLER_41_505 VGND VGND VPWR VPWR sky130_fd_sc_hd__decap_3
XFILLER_53_343 VGND VGND VPWR VPWR sky130_fd_sc_hd__decap_3
XFILLER_81_663 VGND VGND VPWR VPWR sky130_fd_sc_hd__decap_3
X_6977_ clkload1/A _6977_/D VGND VGND VPWR VPWR _6977_/Q sky130_fd_sc_hd__dfxtp_2
XFILLER_110_12 VGND VGND VPWR VPWR sky130_fd_sc_hd__fill_1
XFILLER_41_538 VGND VGND VPWR VPWR sky130_fd_sc_hd__decap_3
XFILLER_53_376 VGND VGND VPWR VPWR sky130_fd_sc_hd__decap_3
XFILLER_80_184 VGND VGND VPWR VPWR sky130_fd_sc_hd__decap_3
XFILLER_81_685 VGND VGND VPWR VPWR sky130_fd_sc_hd__decap_3
XFILLER_110_67 VGND VGND VPWR VPWR sky130_fd_sc_hd__decap_3
XFILLER_70_16 VGND VGND VPWR VPWR sky130_fd_sc_hd__fill_1
XFILLER_21_240 VGND VGND VPWR VPWR sky130_fd_sc_hd__decap_3
XFILLER_21_273 VGND VGND VPWR VPWR sky130_fd_sc_hd__fill_1
XFILLER_70_27 VGND VGND VPWR VPWR sky130_fd_sc_hd__fill_1
XFILLER_70_38 VGND VGND VPWR VPWR sky130_fd_sc_hd__decap_3
XFILLER_21_284 VGND VGND VPWR VPWR sky130_fd_sc_hd__decap_3
XFILLER_5_417 VGND VGND VPWR VPWR sky130_fd_sc_hd__decap_3
XFILLER_79_14 VGND VGND VPWR VPWR sky130_fd_sc_hd__decap_3
XFILLER_79_25 VGND VGND VPWR VPWR sky130_fd_sc_hd__decap_3
XFILLER_107_367 VGND VGND VPWR VPWR sky130_fd_sc_hd__decap_3
Xhold981 _7052_/Q VGND VGND VPWR VPWR hold981/X sky130_fd_sc_hd__dlygate4sd3_1
Xhold970 _7026_/Q VGND VGND VPWR VPWR _5602_/A sky130_fd_sc_hd__dlygate4sd3_1
XFILLER_0_144 VGND VGND VPWR VPWR sky130_fd_sc_hd__decap_3
Xhold992 _7387_/Q VGND VGND VPWR VPWR hold992/X sky130_fd_sc_hd__dlygate4sd3_1
XFILLER_103_573 VGND VGND VPWR VPWR sky130_fd_sc_hd__decap_3
XFILLER_76_424 VGND VGND VPWR VPWR sky130_fd_sc_hd__decap_3
XFILLER_88_262 VGND VGND VPWR VPWR sky130_fd_sc_hd__decap_3
XFILLER_95_24 VGND VGND VPWR VPWR sky130_fd_sc_hd__decap_3
XFILLER_95_57 VGND VGND VPWR VPWR sky130_fd_sc_hd__decap_3
XFILLER_48_137 VGND VGND VPWR VPWR sky130_fd_sc_hd__decap_3
XFILLER_63_107 VGND VGND VPWR VPWR sky130_fd_sc_hd__decap_3
XFILLER_64_619 VGND VGND VPWR VPWR sky130_fd_sc_hd__decap_3
XFILLER_91_405 VGND VGND VPWR VPWR sky130_fd_sc_hd__decap_3
XTAP_TAPCELL_ROW_47_817 VGND VPWR sky130_fd_sc_hd__tapvpwrvgnd_1
XFILLER_44_321 VGND VGND VPWR VPWR sky130_fd_sc_hd__decap_3
XFILLER_56_192 VGND VGND VPWR VPWR sky130_fd_sc_hd__decap_3
XFILLER_72_641 VGND VGND VPWR VPWR sky130_fd_sc_hd__decap_3
XFILLER_91_438 VGND VGND VPWR VPWR sky130_fd_sc_hd__fill_2
XFILLER_91_449 VGND VGND VPWR VPWR sky130_fd_sc_hd__decap_3
XFILLER_44_365 VGND VGND VPWR VPWR sky130_fd_sc_hd__decap_3
XFILLER_71_140 VGND VGND VPWR VPWR sky130_fd_sc_hd__decap_3
XTAP_TAPCELL_ROW_63_1008 VGND VPWR sky130_fd_sc_hd__tapvpwrvgnd_1
XFILLER_44_61 VGND VGND VPWR VPWR sky130_fd_sc_hd__decap_3
XFILLER_71_184 VGND VGND VPWR VPWR sky130_fd_sc_hd__decap_3
XTAP_TAPCELL_ROW_27_574 VGND VPWR sky130_fd_sc_hd__tapvpwrvgnd_1
XFILLER_12_240 VGND VGND VPWR VPWR sky130_fd_sc_hd__decap_3
XFILLER_12_262 VGND VGND VPWR VPWR sky130_fd_sc_hd__decap_3
XFILLER_81_9 VGND VGND VPWR VPWR sky130_fd_sc_hd__decap_3
XFILLER_8_200 VGND VGND VPWR VPWR sky130_fd_sc_hd__decap_3
XFILLER_12_295 VGND VGND VPWR VPWR sky130_fd_sc_hd__decap_3
XFILLER_8_244 VGND VGND VPWR VPWR sky130_fd_sc_hd__decap_3
XFILLER_60_82 VGND VGND VPWR VPWR sky130_fd_sc_hd__fill_2
Xoutput508 _3449_/A VGND VGND VPWR VPWR instruction_out[22] sky130_fd_sc_hd__clkdlybuf4s25_1
XFILLER_5_33 VGND VGND VPWR VPWR sky130_fd_sc_hd__decap_3
Xoutput519 _5643_/X VGND VGND VPWR VPWR instruction_out[5] sky130_fd_sc_hd__clkdlybuf4s25_1
XTAP_TAPCELL_ROW_74_1137 VGND VPWR sky130_fd_sc_hd__tapvpwrvgnd_1
XFILLER_99_505 VGND VGND VPWR VPWR sky130_fd_sc_hd__decap_3
XFILLER_113_326 VGND VGND VPWR VPWR sky130_fd_sc_hd__decap_3
XFILLER_113_337 VGND VGND VPWR VPWR sky130_fd_sc_hd__decap_3
XFILLER_99_538 VGND VGND VPWR VPWR sky130_fd_sc_hd__decap_3
XFILLER_79_251 VGND VGND VPWR VPWR sky130_fd_sc_hd__decap_3
X_4190_ _7263_/Q _4418_/A2 _4190_/B1 _7135_/Q _4189_/X VGND VGND VPWR VPWR _4637_/B
+ sky130_fd_sc_hd__a221o_2
XFILLER_79_284 VGND VGND VPWR VPWR sky130_fd_sc_hd__decap_3
XFILLER_10_3 VGND VGND VPWR VPWR sky130_fd_sc_hd__decap_3
XFILLER_39_148 VGND VGND VPWR VPWR sky130_fd_sc_hd__decap_3
XFILLER_55_608 VGND VGND VPWR VPWR sky130_fd_sc_hd__decap_3
XFILLER_94_221 VGND VGND VPWR VPWR sky130_fd_sc_hd__decap_3
XFILLER_82_427 VGND VGND VPWR VPWR sky130_fd_sc_hd__decap_3
XFILLER_94_265 VGND VGND VPWR VPWR sky130_fd_sc_hd__decap_3
XFILLER_35_310 VGND VGND VPWR VPWR sky130_fd_sc_hd__decap_3
XFILLER_47_181 VGND VGND VPWR VPWR sky130_fd_sc_hd__decap_3
XFILLER_85_90 VGND VGND VPWR VPWR sky130_fd_sc_hd__decap_3
X_6900_ _6965_/CLK _6900_/D VGND VGND VPWR VPWR _6900_/Q sky130_fd_sc_hd__dfxtp_2
XFILLER_23_505 VGND VGND VPWR VPWR sky130_fd_sc_hd__fill_1
XFILLER_35_343 VGND VGND VPWR VPWR sky130_fd_sc_hd__decap_3
XFILLER_62_151 VGND VGND VPWR VPWR sky130_fd_sc_hd__decap_3
X_6831_ _6929_/CLK _6831_/D VGND VGND VPWR VPWR _6831_/Q sky130_fd_sc_hd__dfxtp_2
XTAP_TAPCELL_ROW_85_1266 VGND VPWR sky130_fd_sc_hd__tapvpwrvgnd_1
XFILLER_23_538 VGND VGND VPWR VPWR sky130_fd_sc_hd__decap_3
XTAP_TAPCELL_ROW_85_1277 VGND VPWR sky130_fd_sc_hd__tapvpwrvgnd_1
XFILLER_50_357 VGND VGND VPWR VPWR sky130_fd_sc_hd__decap_3
X_6762_ _6976_/CLK _6762_/D VGND VGND VPWR VPWR _6762_/Q sky130_fd_sc_hd__dfxtp_2
X_6693_ _7384_/CLK _6693_/D VGND VGND VPWR VPWR _6693_/Q sky130_fd_sc_hd__dfxtp_2
X_5644_ _6981_/Q _5130_/C _3340_/B _3353_/A VGND VGND VPWR VPWR _5644_/X sky130_fd_sc_hd__o211a_2
XFILLER_108_109 VGND VGND VPWR VPWR sky130_fd_sc_hd__decap_3
X_7314_ clkload2/A _7314_/D _6594_/Y VGND VGND VPWR VPWR _7314_/Q sky130_fd_sc_hd__dfrtp_2
X_5575_ _5575_/A1 _4960_/A _5010_/D VGND VGND VPWR VPWR _7042_/D sky130_fd_sc_hd__a21o_2
X_4526_ _4526_/A0 _7284_/Q _4530_/S VGND VGND VPWR VPWR _7316_/D sky130_fd_sc_hd__mux2_2
XFILLER_116_175 VGND VGND VPWR VPWR sky130_fd_sc_hd__decap_3
XFILLER_116_197 VGND VGND VPWR VPWR sky130_fd_sc_hd__decap_3
X_7245_ _7371_/CLK _7245_/D _6525_/Y VGND VGND VPWR VPWR _7245_/Q sky130_fd_sc_hd__dfrtp_2
X_4457_ _4720_/A _4720_/B _4456_/X VGND VGND VPWR VPWR _4457_/X sky130_fd_sc_hd__o21a_2
XFILLER_104_348 VGND VGND VPWR VPWR sky130_fd_sc_hd__decap_3
X_7176_ _7365_/CLK _7176_/D _6456_/Y VGND VGND VPWR VPWR _7176_/Q sky130_fd_sc_hd__dfrtp_2
XFILLER_98_560 VGND VGND VPWR VPWR sky130_fd_sc_hd__decap_3
XFILLER_58_402 VGND VGND VPWR VPWR sky130_fd_sc_hd__decap_3
X_4388_ _7273_/Q _4437_/A2 _4385_/X _4387_/X VGND VGND VPWR VPWR _4388_/X sky130_fd_sc_hd__a211o_2
XFILLER_100_521 VGND VGND VPWR VPWR sky130_fd_sc_hd__fill_2
XFILLER_112_392 VGND VGND VPWR VPWR sky130_fd_sc_hd__decap_3
XFILLER_58_457 VGND VGND VPWR VPWR sky130_fd_sc_hd__decap_3
XFILLER_85_221 VGND VGND VPWR VPWR sky130_fd_sc_hd__decap_3
XFILLER_85_243 VGND VGND VPWR VPWR sky130_fd_sc_hd__fill_2
X_3339_ _3319_/X _5238_/B _3329_/Y _3339_/C1 VGND VGND VPWR VPWR _3339_/Y sky130_fd_sc_hd__a211oi_2
XFILLER_105_78 VGND VGND VPWR VPWR sky130_fd_sc_hd__decap_3
XFILLER_65_38 VGND VGND VPWR VPWR sky130_fd_sc_hd__decap_3
XFILLER_73_416 VGND VGND VPWR VPWR sky130_fd_sc_hd__decap_3
XFILLER_26_321 VGND VGND VPWR VPWR sky130_fd_sc_hd__decap_3
XFILLER_85_287 VGND VGND VPWR VPWR sky130_fd_sc_hd__fill_1
X_5009_ _5009_/A _5009_/B VGND VGND VPWR VPWR _5010_/D sky130_fd_sc_hd__nor2_2
XFILLER_26_365 VGND VGND VPWR VPWR sky130_fd_sc_hd__decap_3
XFILLER_38_192 VGND VGND VPWR VPWR sky130_fd_sc_hd__decap_3
XFILLER_26_398 VGND VGND VPWR VPWR sky130_fd_sc_hd__decap_3
XFILLER_41_302 VGND VGND VPWR VPWR sky130_fd_sc_hd__decap_3
XFILLER_81_482 VGND VGND VPWR VPWR sky130_fd_sc_hd__decap_3
XFILLER_41_335 VGND VGND VPWR VPWR sky130_fd_sc_hd__fill_1
XFILLER_41_357 VGND VGND VPWR VPWR sky130_fd_sc_hd__decap_3
XTAP_TAPCELL_ROW_24_544 VGND VPWR sky130_fd_sc_hd__tapvpwrvgnd_1
XFILLER_41_379 VGND VGND VPWR VPWR sky130_fd_sc_hd__fill_2
XTAP_TAPCELL_ROW_52_875 VGND VPWR sky130_fd_sc_hd__tapvpwrvgnd_1
XFILLER_14_97 VGND VGND VPWR VPWR sky130_fd_sc_hd__decap_3
XFILLER_108_643 VGND VGND VPWR VPWR sky130_fd_sc_hd__fill_1
XFILLER_5_214 VGND VGND VPWR VPWR sky130_fd_sc_hd__decap_3
XFILLER_5_236 VGND VGND VPWR VPWR sky130_fd_sc_hd__decap_3
XFILLER_107_153 VGND VGND VPWR VPWR sky130_fd_sc_hd__decap_3
XFILLER_30_52 VGND VGND VPWR VPWR sky130_fd_sc_hd__decap_3
XFILLER_30_85 VGND VGND VPWR VPWR sky130_fd_sc_hd__decap_3
XFILLER_96_519 VGND VGND VPWR VPWR sky130_fd_sc_hd__decap_3
XFILLER_103_370 VGND VGND VPWR VPWR sky130_fd_sc_hd__decap_3
XFILLER_1_464 VGND VGND VPWR VPWR sky130_fd_sc_hd__decap_3
XFILLER_49_413 VGND VGND VPWR VPWR sky130_fd_sc_hd__decap_3
XFILLER_49_446 VGND VGND VPWR VPWR sky130_fd_sc_hd__fill_2
XFILLER_76_232 VGND VGND VPWR VPWR sky130_fd_sc_hd__decap_3
XFILLER_76_276 VGND VGND VPWR VPWR sky130_fd_sc_hd__decap_3
XFILLER_29_181 VGND VGND VPWR VPWR sky130_fd_sc_hd__decap_3
XFILLER_36_129 VGND VGND VPWR VPWR sky130_fd_sc_hd__decap_3
XFILLER_64_438 VGND VGND VPWR VPWR sky130_fd_sc_hd__fill_2
XFILLER_91_213 VGND VGND VPWR VPWR sky130_fd_sc_hd__decap_3
XPHY_EDGE_ROW_101_Right_101 VGND VGND VPWR VPWR sky130_fd_sc_hd__decap_3
XFILLER_17_332 VGND VGND VPWR VPWR sky130_fd_sc_hd__decap_3
XFILLER_55_60 VGND VGND VPWR VPWR sky130_fd_sc_hd__decap_3
XFILLER_44_151 VGND VGND VPWR VPWR sky130_fd_sc_hd__decap_3
XFILLER_72_460 VGND VGND VPWR VPWR sky130_fd_sc_hd__decap_3
XFILLER_44_184 VGND VGND VPWR VPWR sky130_fd_sc_hd__decap_3
XFILLER_71_81 VGND VGND VPWR VPWR sky130_fd_sc_hd__decap_3
XFILLER_58_3 VGND VGND VPWR VPWR sky130_fd_sc_hd__decap_3
X_5360_ _5360_/A0 _4470_/X _5360_/S VGND VGND VPWR VPWR _7151_/D sky130_fd_sc_hd__mux2_2
XFILLER_99_302 VGND VGND VPWR VPWR sky130_fd_sc_hd__decap_3
XFILLER_114_635 VGND VGND VPWR VPWR sky130_fd_sc_hd__decap_3
X_4311_ _4311_/A _4311_/B _4311_/C VGND VGND VPWR VPWR _4311_/X sky130_fd_sc_hd__or3_2
XFILLER_99_335 VGND VGND VPWR VPWR sky130_fd_sc_hd__fill_1
XFILLER_113_145 VGND VGND VPWR VPWR sky130_fd_sc_hd__decap_3
XFILLER_4_291 VGND VGND VPWR VPWR sky130_fd_sc_hd__decap_3
XFILLER_87_508 VGND VGND VPWR VPWR sky130_fd_sc_hd__fill_1
X_7030_ clkload3/A _7030_/D _6310_/Y VGND VGND VPWR VPWR _7030_/Q sky130_fd_sc_hd__dfrtp_2
XFILLER_99_379 VGND VGND VPWR VPWR sky130_fd_sc_hd__decap_3
XFILLER_113_167 VGND VGND VPWR VPWR sky130_fd_sc_hd__fill_1
XFILLER_113_189 VGND VGND VPWR VPWR sky130_fd_sc_hd__decap_3
XFILLER_67_210 VGND VGND VPWR VPWR sky130_fd_sc_hd__decap_3
XFILLER_67_243 VGND VGND VPWR VPWR sky130_fd_sc_hd__decap_3
XFILLER_95_541 VGND VGND VPWR VPWR sky130_fd_sc_hd__decap_3
X_4173_ _7072_/Q VGND VGND VPWR VPWR _4173_/Y sky130_fd_sc_hd__inv_2
XFILLER_67_276 VGND VGND VPWR VPWR sky130_fd_sc_hd__fill_1
XFILLER_55_427 VGND VGND VPWR VPWR sky130_fd_sc_hd__decap_3
XFILLER_55_449 VGND VGND VPWR VPWR sky130_fd_sc_hd__decap_3
XFILLER_67_287 VGND VGND VPWR VPWR sky130_fd_sc_hd__decap_3
XFILLER_35_140 VGND VGND VPWR VPWR sky130_fd_sc_hd__decap_3
XFILLER_36_641 VGND VGND VPWR VPWR sky130_fd_sc_hd__decap_3
XFILLER_35_162 VGND VGND VPWR VPWR sky130_fd_sc_hd__decap_3
XFILLER_63_460 VGND VGND VPWR VPWR sky130_fd_sc_hd__decap_3
XFILLER_63_482 VGND VGND VPWR VPWR sky130_fd_sc_hd__decap_3
XFILLER_23_357 VGND VGND VPWR VPWR sky130_fd_sc_hd__decap_3
XFILLER_35_195 VGND VGND VPWR VPWR sky130_fd_sc_hd__decap_3
XFILLER_50_121 VGND VGND VPWR VPWR sky130_fd_sc_hd__decap_3
Xplace460 _6981_/Q VGND VGND VPWR VPWR _3327_/A sky130_fd_sc_hd__buf_2
X_6814_ _6936_/CLK _6814_/D VGND VGND VPWR VPWR _6814_/Q sky130_fd_sc_hd__dfxtp_2
XFILLER_50_165 VGND VGND VPWR VPWR sky130_fd_sc_hd__decap_3
XFILLER_51_18 VGND VGND VPWR VPWR sky130_fd_sc_hd__decap_3
X_6745_ _6967_/CLK _6745_/D VGND VGND VPWR VPWR _6745_/Q sky130_fd_sc_hd__dfxtp_2
XTAP_TAPCELL_ROW_21_503 VGND VPWR sky130_fd_sc_hd__tapvpwrvgnd_1
X_6676_ _6684_/A VGND VGND VPWR VPWR _6676_/Y sky130_fd_sc_hd__inv_2
X_3888_ _6844_/Q _3892_/A2 _3888_/B1 _6839_/Q VGND VGND VPWR VPWR _3888_/X sky130_fd_sc_hd__a22o_2
XTAP_TAPCELL_ROW_98_1424 VGND VPWR sky130_fd_sc_hd__tapvpwrvgnd_1
XFILLER_104_101 VGND VGND VPWR VPWR sky130_fd_sc_hd__decap_3
X_4509_ _4509_/A1 _3398_/Y _4244_/X VGND VGND VPWR VPWR _7325_/D sky130_fd_sc_hd__a21o_2
XFILLER_104_123 VGND VGND VPWR VPWR sky130_fd_sc_hd__fill_2
X_7228_ _7401_/CLK _7228_/D _6508_/Y VGND VGND VPWR VPWR _7228_/Q sky130_fd_sc_hd__dfrtp_2
XFILLER_104_167 VGND VGND VPWR VPWR sky130_fd_sc_hd__fill_1
XFILLER_104_189 VGND VGND VPWR VPWR sky130_fd_sc_hd__decap_3
XFILLER_116_44 VGND VGND VPWR VPWR sky130_fd_sc_hd__decap_3
XFILLER_116_55 VGND VGND VPWR VPWR sky130_fd_sc_hd__fill_1
XFILLER_116_77 VGND VGND VPWR VPWR sky130_fd_sc_hd__decap_3
XFILLER_58_221 VGND VGND VPWR VPWR sky130_fd_sc_hd__decap_3
XFILLER_76_26 VGND VGND VPWR VPWR sky130_fd_sc_hd__fill_2
X_7159_ clkload5/A _7159_/D _6439_/Y VGND VGND VPWR VPWR _7159_/Q sky130_fd_sc_hd__dfrtp_2
XFILLER_58_276 VGND VGND VPWR VPWR sky130_fd_sc_hd__decap_3
XFILLER_76_59 VGND VGND VPWR VPWR sky130_fd_sc_hd__decap_3
XFILLER_86_574 VGND VGND VPWR VPWR sky130_fd_sc_hd__decap_3
XFILLER_86_585 VGND VGND VPWR VPWR sky130_fd_sc_hd__decap_3
XTAP_TAPCELL_ROW_29_603 VGND VPWR sky130_fd_sc_hd__tapvpwrvgnd_1
XFILLER_100_395 VGND VGND VPWR VPWR sky130_fd_sc_hd__decap_3
XTAP_TAPCELL_ROW_57_934 VGND VPWR sky130_fd_sc_hd__tapvpwrvgnd_1
Xclkbuf_leaf_38_clk clkbuf_3_0__f_clk/X VGND VGND VPWR VPWR clkload2/A sky130_fd_sc_hd__clkbuf_16
XTAP_TAPCELL_ROW_1_261 VGND VPWR sky130_fd_sc_hd__tapvpwrvgnd_1
XTAP_TAPCELL_ROW_107_1531 VGND VPWR sky130_fd_sc_hd__tapvpwrvgnd_1
XFILLER_14_302 VGND VGND VPWR VPWR sky130_fd_sc_hd__decap_3
XFILLER_25_30 VGND VGND VPWR VPWR sky130_fd_sc_hd__decap_3
XFILLER_26_162 VGND VGND VPWR VPWR sky130_fd_sc_hd__decap_3
XFILLER_26_173 VGND VGND VPWR VPWR sky130_fd_sc_hd__decap_3
XFILLER_54_471 VGND VGND VPWR VPWR sky130_fd_sc_hd__decap_3
XFILLER_92_58 VGND VGND VPWR VPWR sky130_fd_sc_hd__decap_3
XFILLER_25_63 VGND VGND VPWR VPWR sky130_fd_sc_hd__decap_3
XFILLER_41_110 VGND VGND VPWR VPWR sky130_fd_sc_hd__fill_2
XFILLER_81_290 VGND VGND VPWR VPWR sky130_fd_sc_hd__decap_3
XTAP_TAPCELL_ROW_37_691 VGND VPWR sky130_fd_sc_hd__tapvpwrvgnd_1
XFILLER_14_368 VGND VGND VPWR VPWR sky130_fd_sc_hd__fill_2
XFILLER_25_96 VGND VGND VPWR VPWR sky130_fd_sc_hd__decap_3
XFILLER_10_541 VGND VGND VPWR VPWR sky130_fd_sc_hd__decap_3
XFILLER_10_563 VGND VGND VPWR VPWR sky130_fd_sc_hd__fill_1
XFILLER_10_585 VGND VGND VPWR VPWR sky130_fd_sc_hd__decap_3
XFILLER_41_84 VGND VGND VPWR VPWR sky130_fd_sc_hd__decap_3
XFILLER_108_462 VGND VGND VPWR VPWR sky130_fd_sc_hd__decap_3
XFILLER_41_95 VGND VGND VPWR VPWR sky130_fd_sc_hd__decap_3
XFILLER_69_508 VGND VGND VPWR VPWR sky130_fd_sc_hd__decap_3
XTAP_TAPCELL_ROW_9_361 VGND VPWR sky130_fd_sc_hd__tapvpwrvgnd_1
XTAP_TAPCELL_ROW_71_1107 VGND VPWR sky130_fd_sc_hd__tapvpwrvgnd_1
XPHY_EDGE_ROW_102_Left_219 VGND VGND VPWR VPWR sky130_fd_sc_hd__decap_3
XFILLER_110_104 VGND VGND VPWR VPWR sky130_fd_sc_hd__decap_3
XFILLER_96_327 VGND VGND VPWR VPWR sky130_fd_sc_hd__decap_3
XFILLER_110_115 VGND VGND VPWR VPWR sky130_fd_sc_hd__decap_3
XFILLER_89_390 VGND VGND VPWR VPWR sky130_fd_sc_hd__fill_2
XFILLER_110_159 VGND VGND VPWR VPWR sky130_fd_sc_hd__fill_2
XFILLER_2_45 VGND VGND VPWR VPWR sky130_fd_sc_hd__decap_3
XFILLER_2_67 VGND VGND VPWR VPWR sky130_fd_sc_hd__fill_1
XFILLER_49_265 VGND VGND VPWR VPWR sky130_fd_sc_hd__fill_1
XFILLER_77_574 VGND VGND VPWR VPWR sky130_fd_sc_hd__decap_3
XFILLER_37_449 VGND VGND VPWR VPWR sky130_fd_sc_hd__decap_3
XFILLER_49_287 VGND VGND VPWR VPWR sky130_fd_sc_hd__decap_3
XFILLER_92_522 VGND VGND VPWR VPWR sky130_fd_sc_hd__fill_2
XFILLER_52_408 VGND VGND VPWR VPWR sky130_fd_sc_hd__decap_3
XFILLER_64_246 VGND VGND VPWR VPWR sky130_fd_sc_hd__decap_3
XFILLER_66_92 VGND VGND VPWR VPWR sky130_fd_sc_hd__decap_3
Xclkbuf_leaf_29_clk clkbuf_3_3__f_clk/X VGND VGND VPWR VPWR _6929_/CLK sky130_fd_sc_hd__clkbuf_16
XFILLER_17_140 VGND VGND VPWR VPWR sky130_fd_sc_hd__fill_2
XFILLER_45_482 VGND VGND VPWR VPWR sky130_fd_sc_hd__decap_3
XFILLER_17_184 VGND VGND VPWR VPWR sky130_fd_sc_hd__decap_3
XFILLER_32_121 VGND VGND VPWR VPWR sky130_fd_sc_hd__decap_3
XFILLER_60_430 VGND VGND VPWR VPWR sky130_fd_sc_hd__decap_3
X_4860_ _4687_/B _4859_/Y _4983_/A VGND VGND VPWR VPWR _4860_/Y sky130_fd_sc_hd__o21ai_2
XTAP_TAPCELL_ROW_82_1236 VGND VPWR sky130_fd_sc_hd__tapvpwrvgnd_1
XPHY_EDGE_ROW_111_Left_228 VGND VGND VPWR VPWR sky130_fd_sc_hd__decap_3
XFILLER_60_463 VGND VGND VPWR VPWR sky130_fd_sc_hd__decap_3
X_3811_ _3682_/A _3808_/X _3810_/X _3741_/X VGND VGND VPWR VPWR _3811_/X sky130_fd_sc_hd__a22o_2
XANTENNA_17 _5656_/A VGND VGND VPWR VPWR sky130_fd_sc_hd__diode_2
XANTENNA_28 _4913_/X VGND VGND VPWR VPWR sky130_fd_sc_hd__diode_2
XFILLER_20_327 VGND VGND VPWR VPWR sky130_fd_sc_hd__decap_3
X_6530_ _6600_/A VGND VGND VPWR VPWR _6530_/Y sky130_fd_sc_hd__inv_2
X_4791_ _4791_/A1 _5664_/A _3697_/Y _3509_/B VGND VGND VPWR VPWR _4791_/Y sky130_fd_sc_hd__a211oi_2
XFILLER_13_390 VGND VGND VPWR VPWR sky130_fd_sc_hd__fill_2
X_3742_ _6833_/Q _3890_/B1 _3892_/B1 _6843_/Q VGND VGND VPWR VPWR _3742_/X sky130_fd_sc_hd__a22o_2
X_6461_ _6651_/A VGND VGND VPWR VPWR _6461_/Y sky130_fd_sc_hd__inv_2
X_3673_ _6856_/Q _6864_/Q _6904_/Q _6912_/Q _3991_/B _3665_/B VGND VGND VPWR VPWR
+ _3673_/X sky130_fd_sc_hd__mux4_2
X_6392_ _6522_/A VGND VGND VPWR VPWR _6392_/Y sky130_fd_sc_hd__inv_2
XFILLER_114_421 VGND VGND VPWR VPWR sky130_fd_sc_hd__decap_3
XTAP_TAPCELL_ROW_93_1365 VGND VPWR sky130_fd_sc_hd__tapvpwrvgnd_1
XFILLER_87_305 VGND VGND VPWR VPWR sky130_fd_sc_hd__decap_3
X_5274_ _5274_/A0 _5079_/X _5274_/S VGND VGND VPWR VPWR _7193_/D sky130_fd_sc_hd__mux2_2
XFILLER_102_638 VGND VGND VPWR VPWR sky130_fd_sc_hd__decap_3
XFILLER_68_530 VGND VGND VPWR VPWR sky130_fd_sc_hd__fill_2
XFILLER_87_349 VGND VGND VPWR VPWR sky130_fd_sc_hd__decap_3
X_7013_ _7258_/CLK _7013_/D _6293_/Y VGND VGND VPWR VPWR _7013_/Q sky130_fd_sc_hd__dfrtp_2
X_4225_ _4371_/A _4371_/B _4224_/C VGND VGND VPWR VPWR _4627_/A sky130_fd_sc_hd__a21oi_2
XFILLER_68_563 VGND VGND VPWR VPWR sky130_fd_sc_hd__decap_3
XFILLER_83_500 VGND VGND VPWR VPWR sky130_fd_sc_hd__decap_3
X_4156_ _4157_/A _4205_/C VGND VGND VPWR VPWR _4158_/A sky130_fd_sc_hd__or2_2
XFILLER_28_449 VGND VGND VPWR VPWR sky130_fd_sc_hd__decap_3
XFILLER_46_18 VGND VGND VPWR VPWR sky130_fd_sc_hd__decap_3
XFILLER_55_213 VGND VGND VPWR VPWR sky130_fd_sc_hd__decap_3
XFILLER_95_393 VGND VGND VPWR VPWR sky130_fd_sc_hd__decap_3
XFILLER_55_246 VGND VGND VPWR VPWR sky130_fd_sc_hd__decap_3
XFILLER_83_555 VGND VGND VPWR VPWR sky130_fd_sc_hd__decap_3
X_4087_ _7078_/Q _4432_/A2 _4432_/B1 _4086_/X VGND VGND VPWR VPWR _4095_/A sky130_fd_sc_hd__o211ai_2
XTAP_TAPCELL_ROW_54_904 VGND VPWR sky130_fd_sc_hd__tapvpwrvgnd_1
XFILLER_102_46 VGND VGND VPWR VPWR sky130_fd_sc_hd__decap_3
XFILLER_43_419 VGND VGND VPWR VPWR sky130_fd_sc_hd__decap_3
XFILLER_55_279 VGND VGND VPWR VPWR sky130_fd_sc_hd__fill_1
XFILLER_83_588 VGND VGND VPWR VPWR sky130_fd_sc_hd__decap_3
XFILLER_102_57 VGND VGND VPWR VPWR sky130_fd_sc_hd__decap_3
XFILLER_63_290 VGND VGND VPWR VPWR sky130_fd_sc_hd__decap_3
XFILLER_70_238 VGND VGND VPWR VPWR sky130_fd_sc_hd__decap_3
XFILLER_11_305 VGND VGND VPWR VPWR sky130_fd_sc_hd__decap_3
XFILLER_51_452 VGND VGND VPWR VPWR sky130_fd_sc_hd__decap_3
Xplace290 _3906_/B1 VGND VGND VPWR VPWR _3889_/B1 sky130_fd_sc_hd__buf_2
XTAP_TAPCELL_ROW_34_661 VGND VPWR sky130_fd_sc_hd__tapvpwrvgnd_1
XFILLER_11_327 VGND VGND VPWR VPWR sky130_fd_sc_hd__decap_3
XFILLER_23_187 VGND VGND VPWR VPWR sky130_fd_sc_hd__decap_3
X_4989_ _5032_/A _5032_/B VGND VGND VPWR VPWR _4989_/X sky130_fd_sc_hd__or2b_2
XTAP_TAPCELL_ROW_62_992 VGND VPWR sky130_fd_sc_hd__tapvpwrvgnd_1
XTAP_TAPCELL_ROW_102_1472 VGND VPWR sky130_fd_sc_hd__tapvpwrvgnd_1
X_6728_ _6978_/CLK _6728_/D VGND VGND VPWR VPWR _6728_/Q sky130_fd_sc_hd__dfxtp_2
XFILLER_109_215 VGND VGND VPWR VPWR sky130_fd_sc_hd__decap_3
X_6659_ _6660_/A VGND VGND VPWR VPWR _6659_/Y sky130_fd_sc_hd__inv_2
XFILLER_105_432 VGND VGND VPWR VPWR sky130_fd_sc_hd__decap_3
XFILLER_11_87 VGND VGND VPWR VPWR sky130_fd_sc_hd__decap_3
XFILLER_105_476 VGND VGND VPWR VPWR sky130_fd_sc_hd__decap_3
XFILLER_78_327 VGND VGND VPWR VPWR sky130_fd_sc_hd__fill_2
XFILLER_87_36 VGND VGND VPWR VPWR sky130_fd_sc_hd__decap_3
XFILLER_105_498 VGND VGND VPWR VPWR sky130_fd_sc_hd__decap_3
XFILLER_59_530 VGND VGND VPWR VPWR sky130_fd_sc_hd__decap_3
XFILLER_78_338 VGND VGND VPWR VPWR sky130_fd_sc_hd__decap_3
XTAP_TAPCELL_ROW_6_320 VGND VPWR sky130_fd_sc_hd__tapvpwrvgnd_1
XFILLER_19_405 VGND VGND VPWR VPWR sky130_fd_sc_hd__decap_3
XFILLER_93_319 VGND VGND VPWR VPWR sky130_fd_sc_hd__decap_3
XFILLER_101_682 VGND VGND VPWR VPWR sky130_fd_sc_hd__fill_2
XFILLER_46_224 VGND VGND VPWR VPWR sky130_fd_sc_hd__decap_3
XFILLER_59_596 VGND VGND VPWR VPWR sky130_fd_sc_hd__fill_2
XFILLER_74_511 VGND VGND VPWR VPWR sky130_fd_sc_hd__decap_3
XFILLER_74_533 VGND VGND VPWR VPWR sky130_fd_sc_hd__decap_3
XFILLER_86_360 VGND VGND VPWR VPWR sky130_fd_sc_hd__decap_3
XFILLER_86_371 VGND VGND VPWR VPWR sky130_fd_sc_hd__decap_3
XFILLER_100_192 VGND VGND VPWR VPWR sky130_fd_sc_hd__decap_3
XFILLER_19_449 VGND VGND VPWR VPWR sky130_fd_sc_hd__decap_3
XFILLER_74_566 VGND VGND VPWR VPWR sky130_fd_sc_hd__decap_3
XFILLER_27_460 VGND VGND VPWR VPWR sky130_fd_sc_hd__decap_3
XFILLER_36_62 VGND VGND VPWR VPWR sky130_fd_sc_hd__decap_3
XFILLER_61_205 VGND VGND VPWR VPWR sky130_fd_sc_hd__decap_3
XFILLER_54_290 VGND VGND VPWR VPWR sky130_fd_sc_hd__decap_3
XFILLER_30_603 VGND VGND VPWR VPWR sky130_fd_sc_hd__decap_3
XFILLER_30_625 VGND VGND VPWR VPWR sky130_fd_sc_hd__fill_1
XFILLER_52_83 VGND VGND VPWR VPWR sky130_fd_sc_hd__fill_1
XFILLER_10_360 VGND VGND VPWR VPWR sky130_fd_sc_hd__decap_3
XFILLER_10_371 VGND VGND VPWR VPWR sky130_fd_sc_hd__decap_3
XFILLER_6_353 VGND VGND VPWR VPWR sky130_fd_sc_hd__decap_3
XTAP_TAPCELL_ROW_12_399 VGND VPWR sky130_fd_sc_hd__tapvpwrvgnd_1
XFILLER_42_6 VGND VGND VPWR VPWR sky130_fd_sc_hd__decap_3
XFILLER_111_402 VGND VGND VPWR VPWR sky130_fd_sc_hd__decap_3
XFILLER_97_614 VGND VGND VPWR VPWR sky130_fd_sc_hd__fill_2
XFILLER_111_435 VGND VGND VPWR VPWR sky130_fd_sc_hd__decap_3
XFILLER_96_124 VGND VGND VPWR VPWR sky130_fd_sc_hd__decap_3
XFILLER_97_647 VGND VGND VPWR VPWR sky130_fd_sc_hd__decap_3
XFILLER_111_457 VGND VGND VPWR VPWR sky130_fd_sc_hd__decap_3
XFILLER_96_168 VGND VGND VPWR VPWR sky130_fd_sc_hd__decap_3
XFILLER_65_511 VGND VGND VPWR VPWR sky130_fd_sc_hd__decap_3
XFILLER_77_393 VGND VGND VPWR VPWR sky130_fd_sc_hd__decap_3
XFILLER_37_246 VGND VGND VPWR VPWR sky130_fd_sc_hd__fill_2
XFILLER_92_330 VGND VGND VPWR VPWR sky130_fd_sc_hd__decap_3
XFILLER_92_352 VGND VGND VPWR VPWR sky130_fd_sc_hd__decap_3
XFILLER_52_205 VGND VGND VPWR VPWR sky130_fd_sc_hd__decap_3
XFILLER_65_599 VGND VGND VPWR VPWR sky130_fd_sc_hd__decap_3
XFILLER_80_536 VGND VGND VPWR VPWR sky130_fd_sc_hd__decap_3
X_4912_ _4912_/A _4912_/B VGND VGND VPWR VPWR _6997_/D sky130_fd_sc_hd__nor2_2
XFILLER_33_441 VGND VGND VPWR VPWR sky130_fd_sc_hd__decap_3
XFILLER_33_452 VGND VGND VPWR VPWR sky130_fd_sc_hd__decap_3
X_4843_ _4111_/B _4842_/X _4633_/A VGND VGND VPWR VPWR _4843_/Y sky130_fd_sc_hd__a21oi_2
XTAP_TAPCELL_ROW_31_620 VGND VPWR sky130_fd_sc_hd__tapvpwrvgnd_1
XFILLER_20_135 VGND VGND VPWR VPWR sky130_fd_sc_hd__decap_3
X_4774_ _7004_/Q _4801_/A VGND VGND VPWR VPWR _4775_/B sky130_fd_sc_hd__nor2_2
XFILLER_20_168 VGND VGND VPWR VPWR sky130_fd_sc_hd__decap_3
X_6513_ _6578_/A VGND VGND VPWR VPWR _6513_/Y sky130_fd_sc_hd__inv_2
X_3725_ _3735_/A _3741_/B _3733_/C VGND VGND VPWR VPWR _3725_/X sky130_fd_sc_hd__and3_2
Xclkbuf_leaf_9_clk clkbuf_leaf_9_clk/A VGND VGND VPWR VPWR _7396_/CLK sky130_fd_sc_hd__clkbuf_16
X_6444_ _6604_/A VGND VGND VPWR VPWR _6444_/Y sky130_fd_sc_hd__inv_2
X_3656_ _3991_/B _3665_/B VGND VGND VPWR VPWR _3656_/Y sky130_fd_sc_hd__nor2_2
X_6375_ _6568_/A VGND VGND VPWR VPWR _6375_/Y sky130_fd_sc_hd__inv_2
X_3587_ _3599_/A _3600_/A VGND VGND VPWR VPWR _4292_/B sky130_fd_sc_hd__or2_4
XFILLER_102_402 VGND VGND VPWR VPWR sky130_fd_sc_hd__decap_3
XFILLER_114_240 VGND VGND VPWR VPWR sky130_fd_sc_hd__fill_1
XFILLER_87_102 VGND VGND VPWR VPWR sky130_fd_sc_hd__decap_3
XFILLER_102_424 VGND VGND VPWR VPWR sky130_fd_sc_hd__decap_3
XFILLER_87_146 VGND VGND VPWR VPWR sky130_fd_sc_hd__fill_1
X_4208_ _4886_/A _4208_/B VGND VGND VPWR VPWR _4903_/A sky130_fd_sc_hd__nor2_2
XFILLER_68_371 VGND VGND VPWR VPWR sky130_fd_sc_hd__decap_3
XFILLER_87_179 VGND VGND VPWR VPWR sky130_fd_sc_hd__decap_3
X_5188_ _5188_/A _5194_/B VGND VGND VPWR VPWR _7234_/D sky130_fd_sc_hd__and2_2
XTAP_TAPCELL_ROW_39_720 VGND VPWR sky130_fd_sc_hd__tapvpwrvgnd_1
XFILLER_113_23 VGND VGND VPWR VPWR sky130_fd_sc_hd__decap_3
XFILLER_113_45 VGND VGND VPWR VPWR sky130_fd_sc_hd__decap_3
XFILLER_28_246 VGND VGND VPWR VPWR sky130_fd_sc_hd__fill_2
XFILLER_56_533 VGND VGND VPWR VPWR sky130_fd_sc_hd__fill_2
XFILLER_83_330 VGND VGND VPWR VPWR sky130_fd_sc_hd__decap_3
X_4139_ _4207_/A _4642_/B VGND VGND VPWR VPWR _4886_/A sky130_fd_sc_hd__nor2_2
XFILLER_113_78 VGND VGND VPWR VPWR sky130_fd_sc_hd__decap_3
XFILLER_16_419 VGND VGND VPWR VPWR sky130_fd_sc_hd__fill_1
XFILLER_28_268 VGND VGND VPWR VPWR sky130_fd_sc_hd__decap_3
XFILLER_43_205 VGND VGND VPWR VPWR sky130_fd_sc_hd__decap_3
XFILLER_71_514 VGND VGND VPWR VPWR sky130_fd_sc_hd__decap_3
XFILLER_71_525 VGND VGND VPWR VPWR sky130_fd_sc_hd__decap_3
XFILLER_83_352 VGND VGND VPWR VPWR sky130_fd_sc_hd__decap_3
XFILLER_83_385 VGND VGND VPWR VPWR sky130_fd_sc_hd__decap_3
XFILLER_73_49 VGND VGND VPWR VPWR sky130_fd_sc_hd__fill_1
XFILLER_83_396 VGND VGND VPWR VPWR sky130_fd_sc_hd__decap_3
XTAP_TAPCELL_ROW_104_1501 VGND VPWR sky130_fd_sc_hd__tapvpwrvgnd_1
XFILLER_11_102 VGND VGND VPWR VPWR sky130_fd_sc_hd__decap_3
XFILLER_11_113 VGND VGND VPWR VPWR sky130_fd_sc_hd__decap_3
XFILLER_11_146 VGND VGND VPWR VPWR sky130_fd_sc_hd__decap_3
XFILLER_51_293 VGND VGND VPWR VPWR sky130_fd_sc_hd__decap_3
XFILLER_22_53 VGND VGND VPWR VPWR sky130_fd_sc_hd__decap_3
XFILLER_98_13 VGND VGND VPWR VPWR sky130_fd_sc_hd__decap_3
XTAP_TAPCELL_ROW_115_1630 VGND VPWR sky130_fd_sc_hd__tapvpwrvgnd_1
XFILLER_98_57 VGND VGND VPWR VPWR sky130_fd_sc_hd__decap_3
XFILLER_105_251 VGND VGND VPWR VPWR sky130_fd_sc_hd__decap_3
XFILLER_3_356 VGND VGND VPWR VPWR sky130_fd_sc_hd__decap_3
XFILLER_3_378 VGND VGND VPWR VPWR sky130_fd_sc_hd__decap_3
XFILLER_105_284 VGND VGND VPWR VPWR sky130_fd_sc_hd__decap_3
XFILLER_3_389 VGND VGND VPWR VPWR sky130_fd_sc_hd__decap_3
XFILLER_79_647 VGND VGND VPWR VPWR sky130_fd_sc_hd__decap_3
XFILLER_94_606 VGND VGND VPWR VPWR sky130_fd_sc_hd__fill_1
XFILLER_19_213 VGND VGND VPWR VPWR sky130_fd_sc_hd__decap_3
XFILLER_78_179 VGND VGND VPWR VPWR sky130_fd_sc_hd__decap_3
XFILLER_87_680 VGND VGND VPWR VPWR sky130_fd_sc_hd__fill_2
XFILLER_93_116 VGND VGND VPWR VPWR sky130_fd_sc_hd__decap_3
XFILLER_94_639 VGND VGND VPWR VPWR sky130_fd_sc_hd__decap_3
XFILLER_19_246 VGND VGND VPWR VPWR sky130_fd_sc_hd__decap_3
XFILLER_59_393 VGND VGND VPWR VPWR sky130_fd_sc_hd__decap_3
XFILLER_93_149 VGND VGND VPWR VPWR sky130_fd_sc_hd__decap_3
XFILLER_19_279 VGND VGND VPWR VPWR sky130_fd_sc_hd__fill_1
XTAP_TAPCELL_ROW_66_1039 VGND VPWR sky130_fd_sc_hd__tapvpwrvgnd_1
XFILLER_15_452 VGND VGND VPWR VPWR sky130_fd_sc_hd__decap_3
XFILLER_15_463 VGND VGND VPWR VPWR sky130_fd_sc_hd__fill_1
XFILLER_27_290 VGND VGND VPWR VPWR sky130_fd_sc_hd__decap_3
XFILLER_63_60 VGND VGND VPWR VPWR sky130_fd_sc_hd__fill_1
XTAP_TAPCELL_ROW_17_458 VGND VPWR sky130_fd_sc_hd__tapvpwrvgnd_1
XFILLER_15_485 VGND VGND VPWR VPWR sky130_fd_sc_hd__fill_2
XFILLER_63_71 VGND VGND VPWR VPWR sky130_fd_sc_hd__decap_3
XFILLER_70_580 VGND VGND VPWR VPWR sky130_fd_sc_hd__decap_3
Xclkbuf_3_4__f_clk clkbuf_0_clk/X VGND VGND VPWR VPWR clkbuf_leaf_9_clk/A sky130_fd_sc_hd__clkbuf_16
XTAP_TAPCELL_ROW_45_789 VGND VPWR sky130_fd_sc_hd__tapvpwrvgnd_1
XFILLER_30_433 VGND VGND VPWR VPWR sky130_fd_sc_hd__decap_3
XFILLER_42_293 VGND VGND VPWR VPWR sky130_fd_sc_hd__decap_3
XFILLER_8_11 VGND VGND VPWR VPWR sky130_fd_sc_hd__decap_3
XFILLER_30_466 VGND VGND VPWR VPWR sky130_fd_sc_hd__decap_3
XFILLER_30_477 VGND VGND VPWR VPWR sky130_fd_sc_hd__decap_3
XFILLER_8_55 VGND VGND VPWR VPWR sky130_fd_sc_hd__decap_3
XFILLER_8_77 VGND VGND VPWR VPWR sky130_fd_sc_hd__decap_3
XFILLER_8_88 VGND VGND VPWR VPWR sky130_fd_sc_hd__decap_3
X_3510_ _3330_/Y _3383_/B _3442_/B _3362_/A VGND VGND VPWR VPWR _3510_/X sky130_fd_sc_hd__a2bb2o_2
XFILLER_116_516 VGND VGND VPWR VPWR sky130_fd_sc_hd__decap_3
XFILLER_6_161 VGND VGND VPWR VPWR sky130_fd_sc_hd__decap_3
XFILLER_7_673 VGND VGND VPWR VPWR sky130_fd_sc_hd__fill_1
Xhold607 _6913_/Q VGND VGND VPWR VPWR _6913_/D sky130_fd_sc_hd__dlygate4sd3_1
Xhold618 _6835_/Q VGND VGND VPWR VPWR _6835_/D sky130_fd_sc_hd__dlygate4sd3_1
Xwire582 wire582/A VGND VGND VPWR VPWR wire582/X sky130_fd_sc_hd__buf_2
XFILLER_6_172 VGND VGND VPWR VPWR sky130_fd_sc_hd__decap_3
Xhold629 _6799_/Q VGND VGND VPWR VPWR _6799_/D sky130_fd_sc_hd__dlygate4sd3_1
X_3441_ _7058_/Q _4305_/B _4460_/A _3440_/X VGND VGND VPWR VPWR _3544_/A sky130_fd_sc_hd__o211ai_2
XTAP_TAPCELL_ROW_77_1179 VGND VPWR sky130_fd_sc_hd__tapvpwrvgnd_1
XFILLER_40_3 VGND VGND VPWR VPWR sky130_fd_sc_hd__decap_3
XFILLER_69_102 VGND VGND VPWR VPWR sky130_fd_sc_hd__decap_3
XFILLER_69_113 VGND VGND VPWR VPWR sky130_fd_sc_hd__decap_3
XFILLER_97_411 VGND VGND VPWR VPWR sky130_fd_sc_hd__decap_3
X_5111_ _3610_/A _3603_/Y _4292_/C _3548_/X VGND VGND VPWR VPWR _5111_/X sky130_fd_sc_hd__a31o_2
XTAP_TAPCELL_ROW_90_1335 VGND VPWR sky130_fd_sc_hd__tapvpwrvgnd_1
XFILLER_57_308 VGND VGND VPWR VPWR sky130_fd_sc_hd__decap_3
XFILLER_69_146 VGND VGND VPWR VPWR sky130_fd_sc_hd__decap_3
XFILLER_97_455 VGND VGND VPWR VPWR sky130_fd_sc_hd__decap_3
XFILLER_84_127 VGND VGND VPWR VPWR sky130_fd_sc_hd__decap_3
XFILLER_97_488 VGND VGND VPWR VPWR sky130_fd_sc_hd__decap_3
XFILLER_25_205 VGND VGND VPWR VPWR sky130_fd_sc_hd__decap_3
XFILLER_65_396 VGND VGND VPWR VPWR sky130_fd_sc_hd__decap_3
XFILLER_92_182 VGND VGND VPWR VPWR sky130_fd_sc_hd__decap_3
X_6993_ _7307_/CLK _6993_/D _6273_/Y VGND VGND VPWR VPWR _6993_/Q sky130_fd_sc_hd__dfrtp_2
XFILLER_33_260 VGND VGND VPWR VPWR sky130_fd_sc_hd__decap_3
XFILLER_21_444 VGND VGND VPWR VPWR sky130_fd_sc_hd__decap_3
X_4826_ _4826_/A _4826_/B VGND VGND VPWR VPWR _7001_/D sky130_fd_sc_hd__nor2_2
XFILLER_21_488 VGND VGND VPWR VPWR sky130_fd_sc_hd__decap_3
X_4757_ _4757_/A _4665_/X VGND VGND VPWR VPWR _4759_/A sky130_fd_sc_hd__or2b_2
XFILLER_107_516 VGND VGND VPWR VPWR sky130_fd_sc_hd__decap_3
X_4688_ _7001_/Q _7002_/Q _4687_/B _5605_/B VGND VGND VPWR VPWR _4688_/X sky130_fd_sc_hd__a31o_2
X_3708_ _6801_/Q _3825_/B1 _3863_/A2 _6711_/Q _3707_/X VGND VGND VPWR VPWR _3708_/X
+ sky130_fd_sc_hd__a221o_2
XFILLER_107_549 VGND VGND VPWR VPWR sky130_fd_sc_hd__decap_3
XFILLER_108_12 VGND VGND VPWR VPWR sky130_fd_sc_hd__decap_3
X_6427_ _6558_/A VGND VGND VPWR VPWR _6427_/Y sky130_fd_sc_hd__inv_2
X_3639_ _3636_/Y _3548_/X _3505_/X _5020_/A _3638_/X VGND VGND VPWR VPWR _3639_/X
+ sky130_fd_sc_hd__o221a_2
X_6358_ _6385_/A VGND VGND VPWR VPWR _6358_/Y sky130_fd_sc_hd__inv_2
XFILLER_0_304 VGND VGND VPWR VPWR sky130_fd_sc_hd__fill_1
XFILLER_0_337 VGND VGND VPWR VPWR sky130_fd_sc_hd__decap_3
XFILLER_115_593 VGND VGND VPWR VPWR sky130_fd_sc_hd__fill_2
XFILLER_102_232 VGND VGND VPWR VPWR sky130_fd_sc_hd__decap_3
XFILLER_76_606 VGND VGND VPWR VPWR sky130_fd_sc_hd__fill_1
XFILLER_88_444 VGND VGND VPWR VPWR sky130_fd_sc_hd__decap_3
XFILLER_88_477 VGND VGND VPWR VPWR sky130_fd_sc_hd__decap_3
X_6289_ _6388_/A VGND VGND VPWR VPWR _6289_/Y sky130_fd_sc_hd__inv_2
XFILLER_102_265 VGND VGND VPWR VPWR sky130_fd_sc_hd__decap_3
XFILLER_29_511 VGND VGND VPWR VPWR sky130_fd_sc_hd__decap_3
XFILLER_75_105 VGND VGND VPWR VPWR sky130_fd_sc_hd__decap_3
XFILLER_75_116 VGND VGND VPWR VPWR sky130_fd_sc_hd__decap_3
XTAP_TAPCELL_ROW_110_1571 VGND VPWR sky130_fd_sc_hd__tapvpwrvgnd_1
XFILLER_56_330 VGND VGND VPWR VPWR sky130_fd_sc_hd__decap_3
XFILLER_84_15 VGND VGND VPWR VPWR sky130_fd_sc_hd__decap_3
XFILLER_91_609 VGND VGND VPWR VPWR sky130_fd_sc_hd__decap_3
XFILLER_56_363 VGND VGND VPWR VPWR sky130_fd_sc_hd__fill_1
XFILLER_56_374 VGND VGND VPWR VPWR sky130_fd_sc_hd__decap_3
XFILLER_16_227 VGND VGND VPWR VPWR sky130_fd_sc_hd__decap_3
XFILLER_17_42 VGND VGND VPWR VPWR sky130_fd_sc_hd__decap_3
XFILLER_83_182 VGND VGND VPWR VPWR sky130_fd_sc_hd__decap_3
XFILLER_71_355 VGND VGND VPWR VPWR sky130_fd_sc_hd__decap_3
XTAP_TAPCELL_ROW_14_417 VGND VPWR sky130_fd_sc_hd__tapvpwrvgnd_1
XFILLER_12_444 VGND VGND VPWR VPWR sky130_fd_sc_hd__decap_3
XFILLER_8_404 VGND VGND VPWR VPWR sky130_fd_sc_hd__fill_1
XTAP_TAPCELL_ROW_42_759 VGND VPWR sky130_fd_sc_hd__tapvpwrvgnd_1
XFILLER_12_466 VGND VGND VPWR VPWR sky130_fd_sc_hd__fill_2
XFILLER_113_508 VGND VGND VPWR VPWR sky130_fd_sc_hd__decap_3
XFILLER_79_411 VGND VGND VPWR VPWR sky130_fd_sc_hd__decap_3
XFILLER_67_606 VGND VGND VPWR VPWR sky130_fd_sc_hd__decap_3
XFILLER_67_617 VGND VGND VPWR VPWR sky130_fd_sc_hd__decap_3
XFILLER_79_444 VGND VGND VPWR VPWR sky130_fd_sc_hd__decap_3
XFILLER_79_455 VGND VGND VPWR VPWR sky130_fd_sc_hd__decap_3
XFILLER_66_105 VGND VGND VPWR VPWR sky130_fd_sc_hd__decap_3
XFILLER_79_488 VGND VGND VPWR VPWR sky130_fd_sc_hd__decap_3
XFILLER_94_436 VGND VGND VPWR VPWR sky130_fd_sc_hd__decap_3
XFILLER_82_609 VGND VGND VPWR VPWR sky130_fd_sc_hd__decap_3
XFILLER_47_374 VGND VGND VPWR VPWR sky130_fd_sc_hd__decap_3
XFILLER_47_396 VGND VGND VPWR VPWR sky130_fd_sc_hd__decap_3
XFILLER_74_171 VGND VGND VPWR VPWR sky130_fd_sc_hd__decap_3
XFILLER_90_642 VGND VGND VPWR VPWR sky130_fd_sc_hd__fill_2
XFILLER_62_344 VGND VGND VPWR VPWR sky130_fd_sc_hd__decap_3
XFILLER_74_92 VGND VGND VPWR VPWR sky130_fd_sc_hd__decap_3
XFILLER_15_293 VGND VGND VPWR VPWR sky130_fd_sc_hd__decap_3
X_5660_ _5660_/A _5660_/B _5660_/C _5660_/D VGND VGND VPWR VPWR _5661_/D sky130_fd_sc_hd__and4_2
XFILLER_88_3 VGND VGND VPWR VPWR sky130_fd_sc_hd__fill_1
XFILLER_90_91 VGND VGND VPWR VPWR sky130_fd_sc_hd__decap_3
X_4611_ _4611_/A VGND VGND VPWR VPWR _4611_/Y sky130_fd_sc_hd__inv_2
XFILLER_30_274 VGND VGND VPWR VPWR sky130_fd_sc_hd__decap_3
X_5591_ _5591_/A _5595_/B VGND VGND VPWR VPWR _7032_/D sky130_fd_sc_hd__or2_2
X_7330_ _7330_/CLK _7330_/D _6610_/Y VGND VGND VPWR VPWR _7330_/Q sky130_fd_sc_hd__dfrtp_2
X_4542_ _4542_/A _4569_/B VGND VGND VPWR VPWR _7309_/D sky130_fd_sc_hd__and2_2
XFILLER_116_324 VGND VGND VPWR VPWR sky130_fd_sc_hd__decap_3
X_7261_ _7294_/CLK _7261_/D _6541_/Y VGND VGND VPWR VPWR _7261_/Q sky130_fd_sc_hd__dfrtp_2
XFILLER_116_368 VGND VGND VPWR VPWR sky130_fd_sc_hd__decap_3
X_3424_ _3398_/Y _3419_/Y _3424_/S VGND VGND VPWR VPWR _3590_/C sky130_fd_sc_hd__mux2_4
X_7192_ clkload2/A _7192_/D _6472_/Y VGND VGND VPWR VPWR _7192_/Q sky130_fd_sc_hd__dfrtp_2
XPHY_EDGE_ROW_115_Right_115 VGND VGND VPWR VPWR sky130_fd_sc_hd__decap_3
XFILLER_112_552 VGND VGND VPWR VPWR sky130_fd_sc_hd__decap_3
XFILLER_97_252 VGND VGND VPWR VPWR sky130_fd_sc_hd__decap_3
X_3355_ _3371_/A _5668_/A _3519_/B VGND VGND VPWR VPWR _3355_/Y sky130_fd_sc_hd__o21ai_2
XFILLER_57_116 VGND VGND VPWR VPWR sky130_fd_sc_hd__decap_3
XFILLER_85_414 VGND VGND VPWR VPWR sky130_fd_sc_hd__decap_3
Xhold1104 _7300_/Q VGND VGND VPWR VPWR _4561_/A sky130_fd_sc_hd__dlygate4sd3_1
Xhold1115 _7172_/Q VGND VGND VPWR VPWR _5317_/A0 sky130_fd_sc_hd__dlygate4sd3_1
XFILLER_73_609 VGND VGND VPWR VPWR sky130_fd_sc_hd__decap_3
XFILLER_85_447 VGND VGND VPWR VPWR sky130_fd_sc_hd__fill_1
XFILLER_85_458 VGND VGND VPWR VPWR sky130_fd_sc_hd__decap_3
XFILLER_97_296 VGND VGND VPWR VPWR sky130_fd_sc_hd__decap_3
Xhold1126 _7143_/Q VGND VGND VPWR VPWR _5379_/A0 sky130_fd_sc_hd__dlygate4sd3_1
Xhold1137 _7320_/Q VGND VGND VPWR VPWR _4519_/A1 sky130_fd_sc_hd__dlygate4sd3_1
Xhold1148 _7261_/Q VGND VGND VPWR VPWR _5012_/A0 sky130_fd_sc_hd__dlygate4sd3_1
X_5025_ _6989_/Q _5044_/A _6990_/Q VGND VGND VPWR VPWR _5026_/B sky130_fd_sc_hd__a21oi_2
XFILLER_38_341 VGND VGND VPWR VPWR sky130_fd_sc_hd__decap_3
XFILLER_72_108 VGND VGND VPWR VPWR sky130_fd_sc_hd__decap_3
XFILLER_72_119 VGND VGND VPWR VPWR sky130_fd_sc_hd__decap_3
Xhold1159 _7218_/Q VGND VGND VPWR VPWR _5221_/A sky130_fd_sc_hd__dlygate4sd3_1
XFILLER_53_311 VGND VGND VPWR VPWR sky130_fd_sc_hd__decap_3
XFILLER_54_18 VGND VGND VPWR VPWR sky130_fd_sc_hd__decap_3
XFILLER_54_29 VGND VGND VPWR VPWR sky130_fd_sc_hd__decap_3
XFILLER_81_620 VGND VGND VPWR VPWR sky130_fd_sc_hd__decap_3
XFILLER_53_355 VGND VGND VPWR VPWR sky130_fd_sc_hd__decap_3
XFILLER_65_193 VGND VGND VPWR VPWR sky130_fd_sc_hd__decap_3
XFILLER_80_141 VGND VGND VPWR VPWR sky130_fd_sc_hd__decap_3
X_6976_ _6976_/CLK _6976_/D VGND VGND VPWR VPWR _6976_/Q sky130_fd_sc_hd__dfxtp_2
XFILLER_41_517 VGND VGND VPWR VPWR sky130_fd_sc_hd__fill_1
XFILLER_110_79 VGND VGND VPWR VPWR sky130_fd_sc_hd__decap_3
XFILLER_21_252 VGND VGND VPWR VPWR sky130_fd_sc_hd__decap_3
X_4809_ _7002_/Q _4826_/A VGND VGND VPWR VPWR _7002_/D sky130_fd_sc_hd__xor2_2
XPHY_EDGE_ROW_17_Right_17 VGND VGND VPWR VPWR sky130_fd_sc_hd__decap_3
XFILLER_107_313 VGND VGND VPWR VPWR sky130_fd_sc_hd__decap_3
XFILLER_5_429 VGND VGND VPWR VPWR sky130_fd_sc_hd__decap_3
XFILLER_107_335 VGND VGND VPWR VPWR sky130_fd_sc_hd__fill_1
XFILLER_107_346 VGND VGND VPWR VPWR sky130_fd_sc_hd__decap_3
XFILLER_107_379 VGND VGND VPWR VPWR sky130_fd_sc_hd__decap_3
XTAP_TAPCELL_ROW_112_1600 VGND VPWR sky130_fd_sc_hd__tapvpwrvgnd_1
Xhold982 _7384_/Q VGND VGND VPWR VPWR hold982/X sky130_fd_sc_hd__dlygate4sd3_1
Xhold971 _7043_/Q VGND VGND VPWR VPWR hold971/X sky130_fd_sc_hd__dlygate4sd3_1
Xhold960 _7392_/Q VGND VGND VPWR VPWR hold960/X sky130_fd_sc_hd__dlygate4sd3_1
XFILLER_0_134 VGND VGND VPWR VPWR sky130_fd_sc_hd__decap_3
XFILLER_115_390 VGND VGND VPWR VPWR sky130_fd_sc_hd__fill_2
XFILLER_88_241 VGND VGND VPWR VPWR sky130_fd_sc_hd__decap_3
Xhold993 _7183_/Q VGND VGND VPWR VPWR hold993/X sky130_fd_sc_hd__dlygate4sd3_1
XFILLER_0_167 VGND VGND VPWR VPWR sky130_fd_sc_hd__fill_1
XFILLER_0_178 VGND VGND VPWR VPWR sky130_fd_sc_hd__decap_3
XFILLER_103_585 VGND VGND VPWR VPWR sky130_fd_sc_hd__decap_3
XFILLER_48_116 VGND VGND VPWR VPWR sky130_fd_sc_hd__decap_3
XFILLER_76_414 VGND VGND VPWR VPWR sky130_fd_sc_hd__fill_1
XFILLER_95_36 VGND VGND VPWR VPWR sky130_fd_sc_hd__decap_3
XPHY_EDGE_ROW_26_Right_26 VGND VGND VPWR VPWR sky130_fd_sc_hd__decap_3
XFILLER_28_41 VGND VGND VPWR VPWR sky130_fd_sc_hd__decap_3
XFILLER_48_149 VGND VGND VPWR VPWR sky130_fd_sc_hd__decap_3
XFILLER_76_436 VGND VGND VPWR VPWR sky130_fd_sc_hd__decap_3
XFILLER_95_69 VGND VGND VPWR VPWR sky130_fd_sc_hd__decap_3
XFILLER_76_469 VGND VGND VPWR VPWR sky130_fd_sc_hd__decap_3
XTAP_TAPCELL_ROW_47_818 VGND VPWR sky130_fd_sc_hd__tapvpwrvgnd_1
XFILLER_28_96 VGND VGND VPWR VPWR sky130_fd_sc_hd__decap_3
XFILLER_29_396 VGND VGND VPWR VPWR sky130_fd_sc_hd__decap_3
XFILLER_44_300 VGND VGND VPWR VPWR sky130_fd_sc_hd__decap_3
XFILLER_56_171 VGND VGND VPWR VPWR sky130_fd_sc_hd__decap_3
XFILLER_84_480 VGND VGND VPWR VPWR sky130_fd_sc_hd__decap_3
XFILLER_44_333 VGND VGND VPWR VPWR sky130_fd_sc_hd__decap_3
XFILLER_72_664 VGND VGND VPWR VPWR sky130_fd_sc_hd__fill_2
XFILLER_71_152 VGND VGND VPWR VPWR sky130_fd_sc_hd__decap_3
XFILLER_71_163 VGND VGND VPWR VPWR sky130_fd_sc_hd__decap_3
XTAP_TAPCELL_ROW_63_1009 VGND VPWR sky130_fd_sc_hd__tapvpwrvgnd_1
XTAP_TAPCELL_ROW_27_575 VGND VPWR sky130_fd_sc_hd__tapvpwrvgnd_1
XFILLER_44_73 VGND VGND VPWR VPWR sky130_fd_sc_hd__decap_3
XFILLER_71_196 VGND VGND VPWR VPWR sky130_fd_sc_hd__decap_3
XPHY_EDGE_ROW_35_Right_35 VGND VGND VPWR VPWR sky130_fd_sc_hd__decap_3
XFILLER_12_274 VGND VGND VPWR VPWR sky130_fd_sc_hd__decap_3
XFILLER_8_223 VGND VGND VPWR VPWR sky130_fd_sc_hd__decap_3
XFILLER_60_61 VGND VGND VPWR VPWR sky130_fd_sc_hd__decap_3
XFILLER_8_256 VGND VGND VPWR VPWR sky130_fd_sc_hd__decap_3
Xoutput509 _3449_/C VGND VGND VPWR VPWR instruction_out[23] sky130_fd_sc_hd__clkdlybuf4s25_1
XFILLER_113_305 VGND VGND VPWR VPWR sky130_fd_sc_hd__decap_3
XFILLER_5_45 VGND VGND VPWR VPWR sky130_fd_sc_hd__decap_3
XFILLER_99_517 VGND VGND VPWR VPWR sky130_fd_sc_hd__decap_3
XFILLER_4_473 VGND VGND VPWR VPWR sky130_fd_sc_hd__decap_3
XTAP_TAPCELL_ROW_74_1138 VGND VPWR sky130_fd_sc_hd__tapvpwrvgnd_1
XFILLER_113_349 VGND VGND VPWR VPWR sky130_fd_sc_hd__decap_3
XPHY_EDGE_ROW_44_Right_44 VGND VGND VPWR VPWR sky130_fd_sc_hd__decap_3
XFILLER_39_116 VGND VGND VPWR VPWR sky130_fd_sc_hd__decap_3
XFILLER_67_414 VGND VGND VPWR VPWR sky130_fd_sc_hd__decap_3
XFILLER_79_263 VGND VGND VPWR VPWR sky130_fd_sc_hd__decap_3
XFILLER_94_200 VGND VGND VPWR VPWR sky130_fd_sc_hd__decap_3
XFILLER_0_690 VGND VGND VPWR VPWR sky130_fd_sc_hd__fill_2
XFILLER_67_436 VGND VGND VPWR VPWR sky130_fd_sc_hd__decap_3
XFILLER_94_233 VGND VGND VPWR VPWR sky130_fd_sc_hd__decap_3
XFILLER_94_244 VGND VGND VPWR VPWR sky130_fd_sc_hd__decap_3
XFILLER_48_672 VGND VGND VPWR VPWR sky130_fd_sc_hd__fill_2
XFILLER_67_469 VGND VGND VPWR VPWR sky130_fd_sc_hd__decap_3
XFILLER_82_406 VGND VGND VPWR VPWR sky130_fd_sc_hd__decap_3
XFILLER_82_417 VGND VGND VPWR VPWR sky130_fd_sc_hd__decap_3
XFILLER_82_439 VGND VGND VPWR VPWR sky130_fd_sc_hd__decap_3
XFILLER_94_299 VGND VGND VPWR VPWR sky130_fd_sc_hd__decap_3
XFILLER_47_193 VGND VGND VPWR VPWR sky130_fd_sc_hd__decap_3
X_6830_ _7351_/CLK _6830_/D VGND VGND VPWR VPWR _6830_/Q sky130_fd_sc_hd__dfxtp_2
XFILLER_23_517 VGND VGND VPWR VPWR sky130_fd_sc_hd__decap_3
XFILLER_35_366 VGND VGND VPWR VPWR sky130_fd_sc_hd__decap_3
XFILLER_50_303 VGND VGND VPWR VPWR sky130_fd_sc_hd__decap_3
XFILLER_62_163 VGND VGND VPWR VPWR sky130_fd_sc_hd__decap_3
XFILLER_90_461 VGND VGND VPWR VPWR sky130_fd_sc_hd__decap_3
X_6761_ clkload1/A _6761_/D VGND VGND VPWR VPWR _6761_/Q sky130_fd_sc_hd__dfxtp_2
XTAP_TAPCELL_ROW_85_1267 VGND VPWR sky130_fd_sc_hd__tapvpwrvgnd_1
XFILLER_50_336 VGND VGND VPWR VPWR sky130_fd_sc_hd__decap_3
X_5712_ _7362_/Q hold922/X _5729_/S VGND VGND VPWR VPWR _6706_/D sky130_fd_sc_hd__mux2_2
X_3973_ _7354_/Q _7322_/Q _3994_/S VGND VGND VPWR VPWR _7354_/D sky130_fd_sc_hd__mux2_2
XPHY_EDGE_ROW_53_Right_53 VGND VGND VPWR VPWR sky130_fd_sc_hd__decap_3
XFILLER_31_561 VGND VGND VPWR VPWR sky130_fd_sc_hd__decap_3
X_6692_ clkload1/A _6692_/D VGND VGND VPWR VPWR _6692_/Q sky130_fd_sc_hd__dfxtp_2
X_5643_ _5643_/A VGND VGND VPWR VPWR _5643_/X sky130_fd_sc_hd__buf_1
X_5574_ hold971/X _4960_/A _4983_/X VGND VGND VPWR VPWR _7043_/D sky130_fd_sc_hd__a21o_2
X_7313_ clkload2/A _7313_/D _6593_/Y VGND VGND VPWR VPWR _7313_/Q sky130_fd_sc_hd__dfrtp_2
XFILLER_104_305 VGND VGND VPWR VPWR sky130_fd_sc_hd__decap_3
XFILLER_104_327 VGND VGND VPWR VPWR sky130_fd_sc_hd__decap_3
XFILLER_116_165 VGND VGND VPWR VPWR sky130_fd_sc_hd__decap_3
X_7244_ _7371_/CLK _7244_/D _6524_/Y VGND VGND VPWR VPWR _7244_/Q sky130_fd_sc_hd__dfrtp_2
X_4456_ _4456_/A _4054_/A VGND VGND VPWR VPWR _4456_/X sky130_fd_sc_hd__or2b_2
XPHY_EDGE_ROW_62_Right_62 VGND VGND VPWR VPWR sky130_fd_sc_hd__decap_3
X_7175_ _7338_/CLK _7175_/D _6455_/Y VGND VGND VPWR VPWR _7175_/Q sky130_fd_sc_hd__dfrtp_2
X_4387_ _7241_/Q _4430_/A2 _4430_/B1 _7177_/Q _4386_/X VGND VGND VPWR VPWR _4387_/X
+ sky130_fd_sc_hd__a221o_2
X_3407_ _3421_/B _3421_/C _3417_/C VGND VGND VPWR VPWR _3407_/X sky130_fd_sc_hd__and3_2
XFILLER_85_200 VGND VGND VPWR VPWR sky130_fd_sc_hd__decap_3
XFILLER_98_572 VGND VGND VPWR VPWR sky130_fd_sc_hd__decap_3
XFILLER_100_533 VGND VGND VPWR VPWR sky130_fd_sc_hd__fill_2
XFILLER_105_57 VGND VGND VPWR VPWR sky130_fd_sc_hd__decap_3
XFILLER_100_577 VGND VGND VPWR VPWR sky130_fd_sc_hd__decap_3
XFILLER_58_469 VGND VGND VPWR VPWR sky130_fd_sc_hd__decap_3
XFILLER_85_266 VGND VGND VPWR VPWR sky130_fd_sc_hd__decap_3
XFILLER_38_171 VGND VGND VPWR VPWR sky130_fd_sc_hd__decap_3
XFILLER_45_119 VGND VGND VPWR VPWR sky130_fd_sc_hd__decap_3
XFILLER_66_480 VGND VGND VPWR VPWR sky130_fd_sc_hd__decap_3
XFILLER_73_428 VGND VGND VPWR VPWR sky130_fd_sc_hd__decap_3
X_5008_ _4680_/A _5015_/B _4960_/A VGND VGND VPWR VPWR _5009_/B sky130_fd_sc_hd__a21o_2
XFILLER_26_344 VGND VGND VPWR VPWR sky130_fd_sc_hd__decap_3
XFILLER_53_130 VGND VGND VPWR VPWR sky130_fd_sc_hd__decap_3
XFILLER_81_461 VGND VGND VPWR VPWR sky130_fd_sc_hd__decap_3
XPHY_EDGE_ROW_71_Right_71 VGND VGND VPWR VPWR sky130_fd_sc_hd__decap_3
XFILLER_81_494 VGND VGND VPWR VPWR sky130_fd_sc_hd__decap_3
X_6959_ _6966_/CLK _6959_/D VGND VGND VPWR VPWR _6959_/Q sky130_fd_sc_hd__dfxtp_2
XTAP_TAPCELL_ROW_24_545 VGND VPWR sky130_fd_sc_hd__tapvpwrvgnd_1
XTAP_TAPCELL_ROW_24_534 VGND VPWR sky130_fd_sc_hd__tapvpwrvgnd_1
XFILLER_14_32 VGND VGND VPWR VPWR sky130_fd_sc_hd__decap_3
XTAP_TAPCELL_ROW_52_876 VGND VPWR sky130_fd_sc_hd__tapvpwrvgnd_1
XFILLER_14_65 VGND VGND VPWR VPWR sky130_fd_sc_hd__decap_3
XFILLER_107_110 VGND VGND VPWR VPWR sky130_fd_sc_hd__fill_2
XPHY_EDGE_ROW_15_Left_132 VGND VGND VPWR VPWR sky130_fd_sc_hd__decap_3
XFILLER_30_64 VGND VGND VPWR VPWR sky130_fd_sc_hd__decap_3
XFILLER_5_248 VGND VGND VPWR VPWR sky130_fd_sc_hd__decap_3
XFILLER_5_259 VGND VGND VPWR VPWR sky130_fd_sc_hd__decap_3
XPHY_EDGE_ROW_80_Right_80 VGND VGND VPWR VPWR sky130_fd_sc_hd__decap_3
XFILLER_107_165 VGND VGND VPWR VPWR sky130_fd_sc_hd__decap_3
XFILLER_30_97 VGND VGND VPWR VPWR sky130_fd_sc_hd__decap_3
Xhold790 _6855_/Q VGND VGND VPWR VPWR _6855_/D sky130_fd_sc_hd__dlygate4sd3_1
XFILLER_89_561 VGND VGND VPWR VPWR sky130_fd_sc_hd__decap_3
XFILLER_103_382 VGND VGND VPWR VPWR sky130_fd_sc_hd__decap_3
XFILLER_39_84 VGND VGND VPWR VPWR sky130_fd_sc_hd__decap_3
XFILLER_49_425 VGND VGND VPWR VPWR sky130_fd_sc_hd__decap_3
XFILLER_76_244 VGND VGND VPWR VPWR sky130_fd_sc_hd__decap_3
XFILLER_17_300 VGND VGND VPWR VPWR sky130_fd_sc_hd__fill_2
XFILLER_36_119 VGND VGND VPWR VPWR sky130_fd_sc_hd__fill_1
XFILLER_57_480 VGND VGND VPWR VPWR sky130_fd_sc_hd__decap_3
XFILLER_76_288 VGND VGND VPWR VPWR sky130_fd_sc_hd__decap_3
XFILLER_91_225 VGND VGND VPWR VPWR sky130_fd_sc_hd__decap_3
XPHY_EDGE_ROW_24_Left_141 VGND VGND VPWR VPWR sky130_fd_sc_hd__decap_3
XFILLER_29_193 VGND VGND VPWR VPWR sky130_fd_sc_hd__decap_3
XFILLER_44_141 VGND VGND VPWR VPWR sky130_fd_sc_hd__fill_2
XFILLER_44_163 VGND VGND VPWR VPWR sky130_fd_sc_hd__decap_3
XFILLER_55_83 VGND VGND VPWR VPWR sky130_fd_sc_hd__decap_3
XFILLER_72_472 VGND VGND VPWR VPWR sky130_fd_sc_hd__decap_3
XFILLER_17_399 VGND VGND VPWR VPWR sky130_fd_sc_hd__fill_2
XFILLER_60_645 VGND VGND VPWR VPWR sky130_fd_sc_hd__fill_1
XFILLER_13_561 VGND VGND VPWR VPWR sky130_fd_sc_hd__fill_2
XFILLER_40_380 VGND VGND VPWR VPWR sky130_fd_sc_hd__decap_3
XFILLER_71_60 VGND VGND VPWR VPWR sky130_fd_sc_hd__decap_3
XFILLER_9_532 VGND VGND VPWR VPWR sky130_fd_sc_hd__fill_2
XFILLER_72_6 VGND VGND VPWR VPWR sky130_fd_sc_hd__decap_3
XPHY_EDGE_ROW_33_Left_150 VGND VGND VPWR VPWR sky130_fd_sc_hd__decap_3
XFILLER_113_102 VGND VGND VPWR VPWR sky130_fd_sc_hd__decap_3
XFILLER_113_113 VGND VGND VPWR VPWR sky130_fd_sc_hd__decap_3
X_5290_ _5290_/A0 _5156_/X _5292_/S VGND VGND VPWR VPWR _7184_/D sky130_fd_sc_hd__mux2_2
X_4310_ _7352_/Q _3449_/X _4334_/B1 _7160_/Q VGND VGND VPWR VPWR _4311_/C sky130_fd_sc_hd__a22o_2
XFILLER_4_270 VGND VGND VPWR VPWR sky130_fd_sc_hd__decap_3
X_4241_ _5018_/B _4241_/B VGND VGND VPWR VPWR _5032_/A sky130_fd_sc_hd__or2_2
XFILLER_99_358 VGND VGND VPWR VPWR sky130_fd_sc_hd__decap_3
XFILLER_101_308 VGND VGND VPWR VPWR sky130_fd_sc_hd__decap_3
XFILLER_101_319 VGND VGND VPWR VPWR sky130_fd_sc_hd__decap_3
XFILLER_113_157 VGND VGND VPWR VPWR sky130_fd_sc_hd__fill_1
XFILLER_67_222 VGND VGND VPWR VPWR sky130_fd_sc_hd__fill_2
XFILLER_95_520 VGND VGND VPWR VPWR sky130_fd_sc_hd__decap_3
X_4172_ _4938_/B _4379_/B VGND VGND VPWR VPWR _4936_/A sky130_fd_sc_hd__nor2_2
XFILLER_55_406 VGND VGND VPWR VPWR sky130_fd_sc_hd__decap_3
XFILLER_95_553 VGND VGND VPWR VPWR sky130_fd_sc_hd__decap_3
XFILLER_95_564 VGND VGND VPWR VPWR sky130_fd_sc_hd__decap_3
XFILLER_27_119 VGND VGND VPWR VPWR sky130_fd_sc_hd__decap_3
XFILLER_48_480 VGND VGND VPWR VPWR sky130_fd_sc_hd__decap_3
XFILLER_55_439 VGND VGND VPWR VPWR sky130_fd_sc_hd__decap_3
XFILLER_67_299 VGND VGND VPWR VPWR sky130_fd_sc_hd__fill_2
XFILLER_82_203 VGND VGND VPWR VPWR sky130_fd_sc_hd__decap_3
XFILLER_70_409 VGND VGND VPWR VPWR sky130_fd_sc_hd__decap_3
XFILLER_82_247 VGND VGND VPWR VPWR sky130_fd_sc_hd__decap_3
XFILLER_35_152 VGND VGND VPWR VPWR sky130_fd_sc_hd__fill_1
XFILLER_51_612 VGND VGND VPWR VPWR sky130_fd_sc_hd__decap_3
XFILLER_50_133 VGND VGND VPWR VPWR sky130_fd_sc_hd__fill_2
XFILLER_90_280 VGND VGND VPWR VPWR sky130_fd_sc_hd__decap_3
Xplace450 _4414_/A2 VGND VGND VPWR VPWR _4433_/B sky130_fd_sc_hd__buf_2
Xplace461 _3353_/A VGND VGND VPWR VPWR _3365_/A sky130_fd_sc_hd__buf_2
X_6813_ _6929_/CLK _6813_/D VGND VGND VPWR VPWR _6813_/Q sky130_fd_sc_hd__dfxtp_2
XFILLER_23_369 VGND VGND VPWR VPWR sky130_fd_sc_hd__decap_3
XFILLER_50_144 VGND VGND VPWR VPWR sky130_fd_sc_hd__fill_1
X_6744_ _6909_/CLK _6744_/D VGND VGND VPWR VPWR _6744_/Q sky130_fd_sc_hd__dfxtp_2
X_3956_ _7362_/Q _4499_/A0 _3956_/S VGND VGND VPWR VPWR _7362_/D sky130_fd_sc_hd__mux2_2
XFILLER_50_177 VGND VGND VPWR VPWR sky130_fd_sc_hd__decap_3
X_6675_ _6675_/A VGND VGND VPWR VPWR _6675_/Y sky130_fd_sc_hd__inv_2
XTAP_TAPCELL_ROW_21_504 VGND VPWR sky130_fd_sc_hd__tapvpwrvgnd_1
XFILLER_109_408 VGND VGND VPWR VPWR sky130_fd_sc_hd__fill_2
X_5626_ _5626_/A _5634_/B VGND VGND VPWR VPWR _7015_/D sky130_fd_sc_hd__and2_2
X_3887_ _6694_/Q _3656_/Y _3892_/B1 _6872_/Q _3886_/X VGND VGND VPWR VPWR _3887_/X
+ sky130_fd_sc_hd__a221o_2
XTAP_TAPCELL_ROW_98_1425 VGND VPWR sky130_fd_sc_hd__tapvpwrvgnd_1
XFILLER_105_614 VGND VGND VPWR VPWR sky130_fd_sc_hd__fill_2
XFILLER_2_207 VGND VGND VPWR VPWR sky130_fd_sc_hd__decap_3
XFILLER_104_135 VGND VGND VPWR VPWR sky130_fd_sc_hd__decap_3
XFILLER_105_647 VGND VGND VPWR VPWR sky130_fd_sc_hd__decap_3
X_7227_ clkload7/A _7227_/D _6507_/Y VGND VGND VPWR VPWR _7227_/Q sky130_fd_sc_hd__dfrtp_2
X_4439_ _4440_/A _4650_/B VGND VGND VPWR VPWR _4813_/B sky130_fd_sc_hd__or2_2
XFILLER_58_200 VGND VGND VPWR VPWR sky130_fd_sc_hd__decap_3
XFILLER_58_233 VGND VGND VPWR VPWR sky130_fd_sc_hd__decap_3
XFILLER_76_38 VGND VGND VPWR VPWR sky130_fd_sc_hd__decap_3
XFILLER_86_520 VGND VGND VPWR VPWR sky130_fd_sc_hd__fill_1
XFILLER_86_542 VGND VGND VPWR VPWR sky130_fd_sc_hd__decap_3
X_7158_ clkload4/A _7158_/D _6438_/Y VGND VGND VPWR VPWR _7158_/Q sky130_fd_sc_hd__dfrtp_2
XFILLER_98_380 VGND VGND VPWR VPWR sky130_fd_sc_hd__decap_3
XFILLER_58_266 VGND VGND VPWR VPWR sky130_fd_sc_hd__fill_2
X_7089_ clkload7/A _7089_/D _6369_/Y VGND VGND VPWR VPWR _7089_/Q sky130_fd_sc_hd__dfstp_2
XFILLER_100_363 VGND VGND VPWR VPWR sky130_fd_sc_hd__fill_1
XFILLER_100_374 VGND VGND VPWR VPWR sky130_fd_sc_hd__decap_3
XFILLER_27_620 VGND VGND VPWR VPWR sky130_fd_sc_hd__fill_2
XFILLER_73_225 VGND VGND VPWR VPWR sky130_fd_sc_hd__decap_3
XTAP_TAPCELL_ROW_57_935 VGND VPWR sky130_fd_sc_hd__tapvpwrvgnd_1
XTAP_TAPCELL_ROW_29_604 VGND VPWR sky130_fd_sc_hd__tapvpwrvgnd_1
XFILLER_26_130 VGND VGND VPWR VPWR sky130_fd_sc_hd__decap_3
XFILLER_73_269 VGND VGND VPWR VPWR sky130_fd_sc_hd__decap_3
XTAP_TAPCELL_ROW_107_1532 VGND VPWR sky130_fd_sc_hd__tapvpwrvgnd_1
XFILLER_26_141 VGND VGND VPWR VPWR sky130_fd_sc_hd__decap_3
XTAP_TAPCELL_ROW_1_262 VGND VPWR sky130_fd_sc_hd__tapvpwrvgnd_1
XFILLER_25_42 VGND VGND VPWR VPWR sky130_fd_sc_hd__decap_3
XFILLER_26_185 VGND VGND VPWR VPWR sky130_fd_sc_hd__decap_3
XFILLER_41_122 VGND VGND VPWR VPWR sky130_fd_sc_hd__decap_3
XFILLER_42_623 VGND VGND VPWR VPWR sky130_fd_sc_hd__decap_3
XFILLER_54_483 VGND VGND VPWR VPWR sky130_fd_sc_hd__decap_3
XTAP_TAPCELL_ROW_37_692 VGND VPWR sky130_fd_sc_hd__tapvpwrvgnd_1
XFILLER_25_75 VGND VGND VPWR VPWR sky130_fd_sc_hd__decap_3
XFILLER_22_380 VGND VGND VPWR VPWR sky130_fd_sc_hd__decap_3
XFILLER_10_531 VGND VGND VPWR VPWR sky130_fd_sc_hd__fill_1
XFILLER_41_63 VGND VGND VPWR VPWR sky130_fd_sc_hd__decap_3
XFILLER_108_474 VGND VGND VPWR VPWR sky130_fd_sc_hd__fill_2
XTAP_TAPCELL_ROW_71_1108 VGND VPWR sky130_fd_sc_hd__tapvpwrvgnd_1
XFILLER_111_628 VGND VGND VPWR VPWR sky130_fd_sc_hd__decap_3
XTAP_TAPCELL_ROW_9_362 VGND VPWR sky130_fd_sc_hd__tapvpwrvgnd_1
XFILLER_110_127 VGND VGND VPWR VPWR sky130_fd_sc_hd__fill_1
XFILLER_1_273 VGND VGND VPWR VPWR sky130_fd_sc_hd__decap_3
XFILLER_2_24 VGND VGND VPWR VPWR sky130_fd_sc_hd__decap_3
XFILLER_49_200 VGND VGND VPWR VPWR sky130_fd_sc_hd__decap_3
XFILLER_77_520 VGND VGND VPWR VPWR sky130_fd_sc_hd__decap_3
XFILLER_96_339 VGND VGND VPWR VPWR sky130_fd_sc_hd__decap_3
XFILLER_103_190 VGND VGND VPWR VPWR sky130_fd_sc_hd__decap_3
XFILLER_37_406 VGND VGND VPWR VPWR sky130_fd_sc_hd__decap_3
XFILLER_49_244 VGND VGND VPWR VPWR sky130_fd_sc_hd__decap_3
XFILLER_92_501 VGND VGND VPWR VPWR sky130_fd_sc_hd__decap_3
XFILLER_37_417 VGND VGND VPWR VPWR sky130_fd_sc_hd__decap_3
XFILLER_64_214 VGND VGND VPWR VPWR sky130_fd_sc_hd__decap_3
XFILLER_66_71 VGND VGND VPWR VPWR sky130_fd_sc_hd__decap_3
XFILLER_77_586 VGND VGND VPWR VPWR sky130_fd_sc_hd__decap_3
XFILLER_45_461 VGND VGND VPWR VPWR sky130_fd_sc_hd__decap_3
XFILLER_92_578 VGND VGND VPWR VPWR sky130_fd_sc_hd__fill_1
XFILLER_92_589 VGND VGND VPWR VPWR sky130_fd_sc_hd__fill_1
XFILLER_17_196 VGND VGND VPWR VPWR sky130_fd_sc_hd__decap_3
XTAP_TAPCELL_ROW_82_1237 VGND VPWR sky130_fd_sc_hd__tapvpwrvgnd_1
XFILLER_32_133 VGND VGND VPWR VPWR sky130_fd_sc_hd__decap_3
XFILLER_32_144 VGND VGND VPWR VPWR sky130_fd_sc_hd__decap_3
XFILLER_60_442 VGND VGND VPWR VPWR sky130_fd_sc_hd__decap_3
XFILLER_82_92 VGND VGND VPWR VPWR sky130_fd_sc_hd__decap_3
X_4790_ _4781_/X _4782_/Y _4787_/Y _4948_/A _4789_/X VGND VGND VPWR VPWR _5664_/A
+ sky130_fd_sc_hd__o221a_2
X_3810_ _6846_/Q _3892_/A2 _3889_/B1 _6831_/Q _3809_/X VGND VGND VPWR VPWR _3810_/X
+ sky130_fd_sc_hd__a221o_2
XANTENNA_18 _4671_/B VGND VGND VPWR VPWR sky130_fd_sc_hd__diode_2
XANTENNA_29 _4913_/X VGND VGND VPWR VPWR sky130_fd_sc_hd__diode_2
XFILLER_20_339 VGND VGND VPWR VPWR sky130_fd_sc_hd__decap_3
XFILLER_60_475 VGND VGND VPWR VPWR sky130_fd_sc_hd__fill_1
XFILLER_60_486 VGND VGND VPWR VPWR sky130_fd_sc_hd__decap_3
X_3741_ _3746_/A _3741_/B _3746_/C VGND VGND VPWR VPWR _3741_/X sky130_fd_sc_hd__and3_4
XFILLER_9_340 VGND VGND VPWR VPWR sky130_fd_sc_hd__decap_3
XFILLER_70_3 VGND VGND VPWR VPWR sky130_fd_sc_hd__fill_1
X_6460_ _6558_/A VGND VGND VPWR VPWR _6460_/Y sky130_fd_sc_hd__inv_2
X_3672_ _3746_/A _3746_/B _3733_/C VGND VGND VPWR VPWR _3672_/X sky130_fd_sc_hd__or3_2
XFILLER_9_373 VGND VGND VPWR VPWR sky130_fd_sc_hd__decap_3
X_6391_ _6553_/A VGND VGND VPWR VPWR _6391_/Y sky130_fd_sc_hd__inv_2
X_5411_ _7128_/Q _5094_/X _5419_/S VGND VGND VPWR VPWR _7128_/D sky130_fd_sc_hd__mux2_2
XFILLER_114_400 VGND VGND VPWR VPWR sky130_fd_sc_hd__decap_3
X_5342_ _5342_/A0 _5094_/X _5350_/S VGND VGND VPWR VPWR _7160_/D sky130_fd_sc_hd__mux2_2
XFILLER_99_111 VGND VGND VPWR VPWR sky130_fd_sc_hd__fill_1
XFILLER_114_433 VGND VGND VPWR VPWR sky130_fd_sc_hd__fill_2
XTAP_TAPCELL_ROW_93_1366 VGND VPWR sky130_fd_sc_hd__tapvpwrvgnd_1
XFILLER_99_144 VGND VGND VPWR VPWR sky130_fd_sc_hd__decap_3
XFILLER_101_105 VGND VGND VPWR VPWR sky130_fd_sc_hd__decap_3
XFILLER_102_606 VGND VGND VPWR VPWR sky130_fd_sc_hd__decap_3
XFILLER_114_455 VGND VGND VPWR VPWR sky130_fd_sc_hd__decap_3
XFILLER_114_466 VGND VGND VPWR VPWR sky130_fd_sc_hd__fill_2
XFILLER_114_477 VGND VGND VPWR VPWR sky130_fd_sc_hd__fill_2
XFILLER_87_317 VGND VGND VPWR VPWR sky130_fd_sc_hd__decap_3
X_7012_ _7360_/CLK _7012_/D _6292_/Y VGND VGND VPWR VPWR _7012_/Q sky130_fd_sc_hd__dfrtp_2
XFILLER_101_116 VGND VGND VPWR VPWR sky130_fd_sc_hd__decap_3
XFILLER_68_520 VGND VGND VPWR VPWR sky130_fd_sc_hd__decap_3
X_4224_ _4371_/A _4371_/B _4224_/C VGND VGND VPWR VPWR _4372_/A sky130_fd_sc_hd__and3_2
XFILLER_28_406 VGND VGND VPWR VPWR sky130_fd_sc_hd__decap_3
XFILLER_68_542 VGND VGND VPWR VPWR sky130_fd_sc_hd__decap_3
XFILLER_68_575 VGND VGND VPWR VPWR sky130_fd_sc_hd__decap_3
X_4155_ _4151_/X _4154_/X _4425_/A VGND VGND VPWR VPWR _4205_/C sky130_fd_sc_hd__o21ai_2
XFILLER_110_683 VGND VGND VPWR VPWR sky130_fd_sc_hd__decap_3
XFILLER_55_225 VGND VGND VPWR VPWR sky130_fd_sc_hd__decap_3
XFILLER_83_523 VGND VGND VPWR VPWR sky130_fd_sc_hd__decap_3
XFILLER_55_258 VGND VGND VPWR VPWR sky130_fd_sc_hd__decap_3
XFILLER_83_567 VGND VGND VPWR VPWR sky130_fd_sc_hd__decap_3
X_4086_ _7270_/Q _4422_/A2 _3947_/S _7334_/Q _4085_/X VGND VGND VPWR VPWR _4086_/X
+ sky130_fd_sc_hd__a221o_2
XFILLER_102_25 VGND VGND VPWR VPWR sky130_fd_sc_hd__decap_3
XFILLER_36_461 VGND VGND VPWR VPWR sky130_fd_sc_hd__decap_3
XFILLER_70_217 VGND VGND VPWR VPWR sky130_fd_sc_hd__decap_3
XTAP_TAPCELL_ROW_54_905 VGND VPWR sky130_fd_sc_hd__tapvpwrvgnd_1
XFILLER_23_111 VGND VGND VPWR VPWR sky130_fd_sc_hd__fill_1
XFILLER_23_122 VGND VGND VPWR VPWR sky130_fd_sc_hd__decap_3
XFILLER_62_18 VGND VGND VPWR VPWR sky130_fd_sc_hd__decap_3
XFILLER_23_155 VGND VGND VPWR VPWR sky130_fd_sc_hd__decap_3
XFILLER_51_464 VGND VGND VPWR VPWR sky130_fd_sc_hd__decap_3
XFILLER_62_29 VGND VGND VPWR VPWR sky130_fd_sc_hd__decap_3
Xplace291 _3656_/Y VGND VGND VPWR VPWR _3906_/B1 sky130_fd_sc_hd__buf_2
Xplace280 _3912_/A2 VGND VGND VPWR VPWR _3828_/A2 sky130_fd_sc_hd__buf_2
XFILLER_51_486 VGND VGND VPWR VPWR sky130_fd_sc_hd__decap_3
XFILLER_51_497 VGND VGND VPWR VPWR sky130_fd_sc_hd__decap_3
X_4988_ _4988_/A _4988_/B VGND VGND VPWR VPWR _5004_/A sky130_fd_sc_hd__nor2_2
XTAP_TAPCELL_ROW_62_993 VGND VPWR sky130_fd_sc_hd__tapvpwrvgnd_1
XTAP_TAPCELL_ROW_34_662 VGND VPWR sky130_fd_sc_hd__tapvpwrvgnd_1
XTAP_TAPCELL_ROW_102_1473 VGND VPWR sky130_fd_sc_hd__tapvpwrvgnd_1
X_6727_ clkload1/A _6727_/D VGND VGND VPWR VPWR _6727_/Q sky130_fd_sc_hd__dfxtp_2
X_3939_ _7370_/Q _4482_/A0 _3947_/S VGND VGND VPWR VPWR _7370_/D sky130_fd_sc_hd__mux2_2
X_6658_ _6660_/A VGND VGND VPWR VPWR _6658_/Y sky130_fd_sc_hd__inv_2
XFILLER_109_249 VGND VGND VPWR VPWR sky130_fd_sc_hd__decap_3
X_5609_ _5609_/A _5633_/B VGND VGND VPWR VPWR _7023_/D sky130_fd_sc_hd__or2_2
XFILLER_11_66 VGND VGND VPWR VPWR sky130_fd_sc_hd__decap_3
X_6589_ _6651_/A VGND VGND VPWR VPWR _6589_/Y sky130_fd_sc_hd__inv_2
XFILLER_105_422 VGND VGND VPWR VPWR sky130_fd_sc_hd__fill_1
XFILLER_11_99 VGND VGND VPWR VPWR sky130_fd_sc_hd__decap_3
XFILLER_87_15 VGND VGND VPWR VPWR sky130_fd_sc_hd__decap_3
XFILLER_105_455 VGND VGND VPWR VPWR sky130_fd_sc_hd__decap_3
XFILLER_105_488 VGND VGND VPWR VPWR sky130_fd_sc_hd__decap_3
XFILLER_59_520 VGND VGND VPWR VPWR sky130_fd_sc_hd__decap_3
XTAP_TAPCELL_ROW_6_321 VGND VPWR sky130_fd_sc_hd__tapvpwrvgnd_1
XFILLER_59_542 VGND VGND VPWR VPWR sky130_fd_sc_hd__decap_3
XFILLER_19_417 VGND VGND VPWR VPWR sky130_fd_sc_hd__decap_3
XFILLER_46_203 VGND VGND VPWR VPWR sky130_fd_sc_hd__decap_3
XFILLER_59_575 VGND VGND VPWR VPWR sky130_fd_sc_hd__fill_1
XFILLER_86_383 VGND VGND VPWR VPWR sky130_fd_sc_hd__decap_3
XFILLER_74_545 VGND VGND VPWR VPWR sky130_fd_sc_hd__decap_3
XFILLER_74_578 VGND VGND VPWR VPWR sky130_fd_sc_hd__decap_3
XFILLER_74_589 VGND VGND VPWR VPWR sky130_fd_sc_hd__decap_3
XFILLER_14_100 VGND VGND VPWR VPWR sky130_fd_sc_hd__decap_3
XFILLER_15_634 VGND VGND VPWR VPWR sky130_fd_sc_hd__fill_2
XFILLER_36_74 VGND VGND VPWR VPWR sky130_fd_sc_hd__fill_2
XFILLER_36_85 VGND VGND VPWR VPWR sky130_fd_sc_hd__decap_3
XFILLER_61_228 VGND VGND VPWR VPWR sky130_fd_sc_hd__decap_3
XTAP_TAPCELL_ROW_68_1070 VGND VPWR sky130_fd_sc_hd__tapvpwrvgnd_1
XFILLER_14_144 VGND VGND VPWR VPWR sky130_fd_sc_hd__decap_3
XFILLER_14_155 VGND VGND VPWR VPWR sky130_fd_sc_hd__decap_3
XFILLER_14_177 VGND VGND VPWR VPWR sky130_fd_sc_hd__decap_3
XFILLER_52_95 VGND VGND VPWR VPWR sky130_fd_sc_hd__fill_2
XFILLER_6_321 VGND VGND VPWR VPWR sky130_fd_sc_hd__decap_3
XFILLER_6_365 VGND VGND VPWR VPWR sky130_fd_sc_hd__decap_3
XFILLER_96_103 VGND VGND VPWR VPWR sky130_fd_sc_hd__decap_3
XFILLER_97_604 VGND VGND VPWR VPWR sky130_fd_sc_hd__decap_3
XFILLER_97_626 VGND VGND VPWR VPWR sky130_fd_sc_hd__decap_3
XFILLER_69_328 VGND VGND VPWR VPWR sky130_fd_sc_hd__decap_3
XFILLER_96_136 VGND VGND VPWR VPWR sky130_fd_sc_hd__decap_3
XFILLER_111_447 VGND VGND VPWR VPWR sky130_fd_sc_hd__fill_1
XFILLER_84_309 VGND VGND VPWR VPWR sky130_fd_sc_hd__decap_3
XFILLER_96_147 VGND VGND VPWR VPWR sky130_fd_sc_hd__decap_3
XFILLER_37_203 VGND VGND VPWR VPWR sky130_fd_sc_hd__decap_3
XFILLER_77_361 VGND VGND VPWR VPWR sky130_fd_sc_hd__decap_3
XFILLER_65_534 VGND VGND VPWR VPWR sky130_fd_sc_hd__decap_3
XFILLER_18_450 VGND VGND VPWR VPWR sky130_fd_sc_hd__fill_1
XFILLER_37_269 VGND VGND VPWR VPWR sky130_fd_sc_hd__decap_3
XFILLER_80_504 VGND VGND VPWR VPWR sky130_fd_sc_hd__decap_3
XFILLER_52_228 VGND VGND VPWR VPWR sky130_fd_sc_hd__decap_3
XFILLER_80_548 VGND VGND VPWR VPWR sky130_fd_sc_hd__decap_3
XFILLER_93_91 VGND VGND VPWR VPWR sky130_fd_sc_hd__decap_3
X_4911_ _6997_/Q _4931_/A VGND VGND VPWR VPWR _4912_/B sky130_fd_sc_hd__nor2_2
XFILLER_33_464 VGND VGND VPWR VPWR sky130_fd_sc_hd__decap_3
XFILLER_20_114 VGND VGND VPWR VPWR sky130_fd_sc_hd__decap_3
XFILLER_33_475 VGND VGND VPWR VPWR sky130_fd_sc_hd__decap_3
XFILLER_60_250 VGND VGND VPWR VPWR sky130_fd_sc_hd__fill_2
X_4842_ _4643_/Y _4841_/Y _4845_/A VGND VGND VPWR VPWR _4842_/X sky130_fd_sc_hd__a21o_2
XFILLER_20_147 VGND VGND VPWR VPWR sky130_fd_sc_hd__fill_1
XTAP_TAPCELL_ROW_31_621 VGND VPWR sky130_fd_sc_hd__tapvpwrvgnd_1
X_6512_ _6608_/A VGND VGND VPWR VPWR _6512_/Y sky130_fd_sc_hd__inv_2
X_3724_ _6828_/Q _3892_/A2 _3889_/A2 _6818_/Q _3723_/X VGND VGND VPWR VPWR _3724_/X
+ sky130_fd_sc_hd__a221o_2
X_6443_ _6570_/A VGND VGND VPWR VPWR _6443_/Y sky130_fd_sc_hd__inv_2
XFILLER_9_181 VGND VGND VPWR VPWR sky130_fd_sc_hd__decap_3
X_6374_ _6539_/A VGND VGND VPWR VPWR _6374_/Y sky130_fd_sc_hd__inv_2
X_3586_ _3591_/A _3591_/B _3591_/C _3586_/D VGND VGND VPWR VPWR _3586_/Y sky130_fd_sc_hd__nor4_2
X_5325_ _7168_/Q _4964_/X _5325_/S VGND VGND VPWR VPWR _7168_/D sky130_fd_sc_hd__mux2_2
XFILLER_102_414 VGND VGND VPWR VPWR sky130_fd_sc_hd__fill_2
XFILLER_102_436 VGND VGND VPWR VPWR sky130_fd_sc_hd__fill_1
XFILLER_88_637 VGND VGND VPWR VPWR sky130_fd_sc_hd__decap_3
XFILLER_88_659 VGND VGND VPWR VPWR sky130_fd_sc_hd__decap_3
X_5256_ _5256_/A0 _4932_/X _5262_/S VGND VGND VPWR VPWR _7202_/D sky130_fd_sc_hd__mux2_2
XFILLER_102_458 VGND VGND VPWR VPWR sky130_fd_sc_hd__decap_3
XFILLER_57_18 VGND VGND VPWR VPWR sky130_fd_sc_hd__decap_3
XFILLER_75_309 VGND VGND VPWR VPWR sky130_fd_sc_hd__decap_3
XFILLER_87_169 VGND VGND VPWR VPWR sky130_fd_sc_hd__fill_2
X_4207_ _4207_/A _4642_/B VGND VGND VPWR VPWR _4208_/B sky130_fd_sc_hd__and2_2
XFILLER_28_203 VGND VGND VPWR VPWR sky130_fd_sc_hd__decap_3
XFILLER_56_501 VGND VGND VPWR VPWR sky130_fd_sc_hd__decap_3
XFILLER_56_523 VGND VGND VPWR VPWR sky130_fd_sc_hd__decap_3
XFILLER_68_350 VGND VGND VPWR VPWR sky130_fd_sc_hd__decap_3
XFILLER_68_383 VGND VGND VPWR VPWR sky130_fd_sc_hd__decap_3
XFILLER_96_681 VGND VGND VPWR VPWR sky130_fd_sc_hd__decap_3
XFILLER_28_225 VGND VGND VPWR VPWR sky130_fd_sc_hd__decap_3
X_4138_ _4134_/X _4137_/X _4425_/A VGND VGND VPWR VPWR _4642_/B sky130_fd_sc_hd__o21a_2
XTAP_TAPCELL_ROW_39_721 VGND VPWR sky130_fd_sc_hd__tapvpwrvgnd_1
XFILLER_113_57 VGND VGND VPWR VPWR sky130_fd_sc_hd__decap_3
XFILLER_73_28 VGND VGND VPWR VPWR sky130_fd_sc_hd__decap_3
XFILLER_83_364 VGND VGND VPWR VPWR sky130_fd_sc_hd__decap_3
X_4069_ _4744_/B _4069_/B VGND VGND VPWR VPWR _4610_/A sky130_fd_sc_hd__nor2_2
XFILLER_71_537 VGND VGND VPWR VPWR sky130_fd_sc_hd__decap_3
XTAP_TAPCELL_ROW_104_1502 VGND VPWR sky130_fd_sc_hd__tapvpwrvgnd_1
XFILLER_51_250 VGND VGND VPWR VPWR sky130_fd_sc_hd__decap_3
XFILLER_11_125 VGND VGND VPWR VPWR sky130_fd_sc_hd__decap_3
XFILLER_11_158 VGND VGND VPWR VPWR sky130_fd_sc_hd__decap_3
XFILLER_11_169 VGND VGND VPWR VPWR sky130_fd_sc_hd__decap_3
XFILLER_22_21 VGND VGND VPWR VPWR sky130_fd_sc_hd__decap_3
XFILLER_22_32 VGND VGND VPWR VPWR sky130_fd_sc_hd__decap_3
XFILLER_7_107 VGND VGND VPWR VPWR sky130_fd_sc_hd__decap_3
XFILLER_22_65 VGND VGND VPWR VPWR sky130_fd_sc_hd__decap_3
XFILLER_3_302 VGND VGND VPWR VPWR sky130_fd_sc_hd__decap_3
XTAP_TAPCELL_ROW_115_1631 VGND VPWR sky130_fd_sc_hd__tapvpwrvgnd_1
XFILLER_98_69 VGND VGND VPWR VPWR sky130_fd_sc_hd__decap_3
XFILLER_105_263 VGND VGND VPWR VPWR sky130_fd_sc_hd__decap_3
XFILLER_79_626 VGND VGND VPWR VPWR sky130_fd_sc_hd__decap_3
XFILLER_66_309 VGND VGND VPWR VPWR sky130_fd_sc_hd__decap_3
XFILLER_78_147 VGND VGND VPWR VPWR sky130_fd_sc_hd__decap_3
XFILLER_78_158 VGND VGND VPWR VPWR sky130_fd_sc_hd__decap_3
XFILLER_94_618 VGND VGND VPWR VPWR sky130_fd_sc_hd__decap_3
XFILLER_19_203 VGND VGND VPWR VPWR sky130_fd_sc_hd__fill_1
XFILLER_47_501 VGND VGND VPWR VPWR sky130_fd_sc_hd__decap_3
XFILLER_59_383 VGND VGND VPWR VPWR sky130_fd_sc_hd__decap_3
XFILLER_93_106 VGND VGND VPWR VPWR sky130_fd_sc_hd__decap_3
XFILLER_19_225 VGND VGND VPWR VPWR sky130_fd_sc_hd__decap_3
XFILLER_47_51 VGND VGND VPWR VPWR sky130_fd_sc_hd__decap_3
XFILLER_47_545 VGND VGND VPWR VPWR sky130_fd_sc_hd__decap_3
XFILLER_47_62 VGND VGND VPWR VPWR sky130_fd_sc_hd__decap_3
XFILLER_86_180 VGND VGND VPWR VPWR sky130_fd_sc_hd__fill_1
XFILLER_19_258 VGND VGND VPWR VPWR sky130_fd_sc_hd__decap_3
XFILLER_74_353 VGND VGND VPWR VPWR sky130_fd_sc_hd__decap_3
XFILLER_15_420 VGND VGND VPWR VPWR sky130_fd_sc_hd__decap_3
XFILLER_62_526 VGND VGND VPWR VPWR sky130_fd_sc_hd__decap_3
XTAP_TAPCELL_ROW_17_459 VGND VPWR sky130_fd_sc_hd__tapvpwrvgnd_1
XFILLER_30_401 VGND VGND VPWR VPWR sky130_fd_sc_hd__decap_3
XFILLER_30_412 VGND VGND VPWR VPWR sky130_fd_sc_hd__decap_3
XFILLER_63_83 VGND VGND VPWR VPWR sky130_fd_sc_hd__decap_3
XFILLER_70_592 VGND VGND VPWR VPWR sky130_fd_sc_hd__decap_3
XFILLER_8_23 VGND VGND VPWR VPWR sky130_fd_sc_hd__decap_3
XFILLER_30_489 VGND VGND VPWR VPWR sky130_fd_sc_hd__decap_3
XPHY_EDGE_ROW_7_Left_124 VGND VGND VPWR VPWR sky130_fd_sc_hd__decap_3
XFILLER_11_670 VGND VGND VPWR VPWR sky130_fd_sc_hd__fill_2
XFILLER_116_528 VGND VGND VPWR VPWR sky130_fd_sc_hd__decap_3
Xhold608 _6914_/Q VGND VGND VPWR VPWR _6914_/D sky130_fd_sc_hd__dlygate4sd3_1
XFILLER_109_591 VGND VGND VPWR VPWR sky130_fd_sc_hd__decap_3
Xhold619 _6812_/Q VGND VGND VPWR VPWR _6812_/D sky130_fd_sc_hd__dlygate4sd3_1
X_3440_ _7250_/Q _4601_/S _3434_/X _3439_/X VGND VGND VPWR VPWR _3440_/X sky130_fd_sc_hd__a211o_2
X_3371_ _3371_/A _5118_/D _5118_/A _3362_/A VGND VGND VPWR VPWR _3371_/Y sky130_fd_sc_hd__nor4bb_2
XFILLER_33_3 VGND VGND VPWR VPWR sky130_fd_sc_hd__decap_3
XFILLER_69_125 VGND VGND VPWR VPWR sky130_fd_sc_hd__decap_3
XFILLER_88_91 VGND VGND VPWR VPWR sky130_fd_sc_hd__decap_3
XFILLER_97_423 VGND VGND VPWR VPWR sky130_fd_sc_hd__decap_3
X_5110_ _3610_/A _3603_/Y _4292_/C VGND VGND VPWR VPWR _5110_/Y sky130_fd_sc_hd__a21oi_2
XTAP_TAPCELL_ROW_90_1336 VGND VPWR sky130_fd_sc_hd__tapvpwrvgnd_1
XFILLER_69_158 VGND VGND VPWR VPWR sky130_fd_sc_hd__decap_3
XFILLER_85_607 VGND VGND VPWR VPWR sky130_fd_sc_hd__decap_3
XFILLER_97_467 VGND VGND VPWR VPWR sky130_fd_sc_hd__decap_3
X_5041_ _5041_/A0 _5040_/X _5132_/S VGND VGND VPWR VPWR _7259_/D sky130_fd_sc_hd__mux2_2
XFILLER_111_288 VGND VGND VPWR VPWR sky130_fd_sc_hd__decap_3
XFILLER_69_169 VGND VGND VPWR VPWR sky130_fd_sc_hd__decap_3
XFILLER_84_106 VGND VGND VPWR VPWR sky130_fd_sc_hd__decap_3
XFILLER_65_331 VGND VGND VPWR VPWR sky130_fd_sc_hd__decap_3
XFILLER_84_139 VGND VGND VPWR VPWR sky130_fd_sc_hd__fill_1
XFILLER_38_578 VGND VGND VPWR VPWR sky130_fd_sc_hd__fill_1
XFILLER_80_301 VGND VGND VPWR VPWR sky130_fd_sc_hd__decap_3
XFILLER_92_150 VGND VGND VPWR VPWR sky130_fd_sc_hd__decap_3
XFILLER_25_217 VGND VGND VPWR VPWR sky130_fd_sc_hd__decap_3
XFILLER_25_228 VGND VGND VPWR VPWR sky130_fd_sc_hd__fill_2
XFILLER_25_239 VGND VGND VPWR VPWR sky130_fd_sc_hd__decap_3
XFILLER_80_312 VGND VGND VPWR VPWR sky130_fd_sc_hd__decap_3
XFILLER_92_194 VGND VGND VPWR VPWR sky130_fd_sc_hd__fill_2
X_6992_ _7307_/CLK _6992_/D _6272_/Y VGND VGND VPWR VPWR _6992_/Q sky130_fd_sc_hd__dfrtp_2
XFILLER_18_280 VGND VGND VPWR VPWR sky130_fd_sc_hd__decap_3
XFILLER_53_559 VGND VGND VPWR VPWR sky130_fd_sc_hd__fill_1
XFILLER_80_345 VGND VGND VPWR VPWR sky130_fd_sc_hd__fill_2
XFILLER_80_356 VGND VGND VPWR VPWR sky130_fd_sc_hd__decap_3
XFILLER_33_272 VGND VGND VPWR VPWR sky130_fd_sc_hd__decap_3
XFILLER_61_570 VGND VGND VPWR VPWR sky130_fd_sc_hd__decap_3
X_4825_ _7001_/Q _4825_/B VGND VGND VPWR VPWR _4826_/B sky130_fd_sc_hd__nor2_2
XFILLER_107_528 VGND VGND VPWR VPWR sky130_fd_sc_hd__decap_3
X_4687_ _7001_/Q _4687_/B VGND VGND VPWR VPWR _4834_/A sky130_fd_sc_hd__and2_2
X_3707_ _6937_/Q _3828_/A2 _3827_/B1 _6889_/Q VGND VGND VPWR VPWR _3707_/X sky130_fd_sc_hd__a22o_2
XFILLER_104_9 VGND VGND VPWR VPWR sky130_fd_sc_hd__decap_3
XFILLER_108_24 VGND VGND VPWR VPWR sky130_fd_sc_hd__decap_3
XFILLER_108_35 VGND VGND VPWR VPWR sky130_fd_sc_hd__decap_3
X_6426_ _6616_/A VGND VGND VPWR VPWR _6426_/Y sky130_fd_sc_hd__inv_2
X_3638_ _3635_/A _3618_/C _3547_/A VGND VGND VPWR VPWR _3638_/X sky130_fd_sc_hd__a21bo_2
XFILLER_108_57 VGND VGND VPWR VPWR sky130_fd_sc_hd__fill_1
X_6357_ _6388_/A VGND VGND VPWR VPWR _6357_/Y sky130_fd_sc_hd__inv_2
X_3569_ _7285_/Q _5159_/S _3567_/X _3568_/X VGND VGND VPWR VPWR _3569_/X sky130_fd_sc_hd__a211o_2
XFILLER_102_211 VGND VGND VPWR VPWR sky130_fd_sc_hd__decap_3
X_5308_ _5308_/A0 _4822_/X _5327_/S VGND VGND VPWR VPWR _7176_/D sky130_fd_sc_hd__mux2_2
XFILLER_102_244 VGND VGND VPWR VPWR sky130_fd_sc_hd__decap_3
X_6288_ _6288_/A VGND VGND VPWR VPWR _6288_/Y sky130_fd_sc_hd__inv_2
XFILLER_102_288 VGND VGND VPWR VPWR sky130_fd_sc_hd__decap_3
XFILLER_48_309 VGND VGND VPWR VPWR sky130_fd_sc_hd__decap_3
XFILLER_69_681 VGND VGND VPWR VPWR sky130_fd_sc_hd__decap_3
X_5239_ hold975/X _5238_/X _4766_/A VGND VGND VPWR VPWR _7211_/D sky130_fd_sc_hd__a21o_2
XTAP_TAPCELL_ROW_110_1572 VGND VPWR sky130_fd_sc_hd__tapvpwrvgnd_1
XFILLER_29_534 VGND VGND VPWR VPWR sky130_fd_sc_hd__decap_3
XFILLER_68_191 VGND VGND VPWR VPWR sky130_fd_sc_hd__decap_3
XFILLER_84_27 VGND VGND VPWR VPWR sky130_fd_sc_hd__fill_1
XFILLER_16_206 VGND VGND VPWR VPWR sky130_fd_sc_hd__decap_3
XFILLER_29_556 VGND VGND VPWR VPWR sky130_fd_sc_hd__decap_3
XFILLER_56_342 VGND VGND VPWR VPWR sky130_fd_sc_hd__decap_3
XFILLER_90_109 VGND VGND VPWR VPWR sky130_fd_sc_hd__decap_3
XFILLER_16_239 VGND VGND VPWR VPWR sky130_fd_sc_hd__decap_3
XFILLER_44_548 VGND VGND VPWR VPWR sky130_fd_sc_hd__fill_1
XFILLER_17_76 VGND VGND VPWR VPWR sky130_fd_sc_hd__decap_3
XFILLER_17_98 VGND VGND VPWR VPWR sky130_fd_sc_hd__decap_3
XFILLER_24_272 VGND VGND VPWR VPWR sky130_fd_sc_hd__decap_3
XFILLER_31_209 VGND VGND VPWR VPWR sky130_fd_sc_hd__decap_3
XTAP_TAPCELL_ROW_14_418 VGND VPWR sky130_fd_sc_hd__tapvpwrvgnd_1
XFILLER_33_42 VGND VGND VPWR VPWR sky130_fd_sc_hd__decap_3
XFILLER_8_416 VGND VGND VPWR VPWR sky130_fd_sc_hd__decap_3
XFILLER_4_622 VGND VGND VPWR VPWR sky130_fd_sc_hd__fill_2
XFILLER_3_132 VGND VGND VPWR VPWR sky130_fd_sc_hd__decap_3
XFILLER_79_423 VGND VGND VPWR VPWR sky130_fd_sc_hd__decap_3
XFILLER_3_198 VGND VGND VPWR VPWR sky130_fd_sc_hd__decap_3
XFILLER_79_467 VGND VGND VPWR VPWR sky130_fd_sc_hd__decap_3
XFILLER_58_61 VGND VGND VPWR VPWR sky130_fd_sc_hd__decap_3
XFILLER_58_83 VGND VGND VPWR VPWR sky130_fd_sc_hd__fill_1
XFILLER_94_415 VGND VGND VPWR VPWR sky130_fd_sc_hd__decap_3
XFILLER_47_320 VGND VGND VPWR VPWR sky130_fd_sc_hd__decap_3
XFILLER_59_191 VGND VGND VPWR VPWR sky130_fd_sc_hd__decap_3
XFILLER_66_128 VGND VGND VPWR VPWR sky130_fd_sc_hd__decap_3
XFILLER_74_150 VGND VGND VPWR VPWR sky130_fd_sc_hd__decap_3
XFILLER_47_386 VGND VGND VPWR VPWR sky130_fd_sc_hd__decap_3
XFILLER_62_323 VGND VGND VPWR VPWR sky130_fd_sc_hd__decap_3
XFILLER_74_183 VGND VGND VPWR VPWR sky130_fd_sc_hd__decap_3
XFILLER_75_684 VGND VGND VPWR VPWR sky130_fd_sc_hd__decap_3
XFILLER_62_356 VGND VGND VPWR VPWR sky130_fd_sc_hd__decap_3
XFILLER_15_261 VGND VGND VPWR VPWR sky130_fd_sc_hd__decap_3
XFILLER_22_209 VGND VGND VPWR VPWR sky130_fd_sc_hd__decap_3
XFILLER_62_389 VGND VGND VPWR VPWR sky130_fd_sc_hd__decap_3
XFILLER_30_253 VGND VGND VPWR VPWR sky130_fd_sc_hd__decap_3
X_4610_ _4610_/A _4762_/B VGND VGND VPWR VPWR _4611_/A sky130_fd_sc_hd__nand2_2
XFILLER_30_286 VGND VGND VPWR VPWR sky130_fd_sc_hd__decap_3
X_7260_ _7294_/CLK _7260_/D _6540_/Y VGND VGND VPWR VPWR _7260_/Q sky130_fd_sc_hd__dfrtp_2
X_7191_ _7381_/CLK _7191_/D _6471_/Y VGND VGND VPWR VPWR _7191_/Q sky130_fd_sc_hd__dfrtp_2
X_3423_ _3442_/A _3442_/B _4289_/B VGND VGND VPWR VPWR _3424_/S sky130_fd_sc_hd__and3_4
XFILLER_97_220 VGND VGND VPWR VPWR sky130_fd_sc_hd__decap_3
XFILLER_97_231 VGND VGND VPWR VPWR sky130_fd_sc_hd__fill_2
X_3354_ _3327_/A _5668_/A _3328_/B _3561_/B VGND VGND VPWR VPWR _3354_/X sky130_fd_sc_hd__a211o_2
XFILLER_85_426 VGND VGND VPWR VPWR sky130_fd_sc_hd__decap_3
XFILLER_97_264 VGND VGND VPWR VPWR sky130_fd_sc_hd__decap_3
Xhold1105 _7403_/Q VGND VGND VPWR VPWR _3693_/A0 sky130_fd_sc_hd__dlygate4sd3_1
XFILLER_57_128 VGND VGND VPWR VPWR sky130_fd_sc_hd__decap_3
Xhold1116 _7175_/Q VGND VGND VPWR VPWR _5310_/A0 sky130_fd_sc_hd__dlygate4sd3_1
Xhold1127 _7330_/Q VGND VGND VPWR VPWR _4499_/A0 sky130_fd_sc_hd__dlygate4sd3_1
Xhold1138 _7319_/Q VGND VGND VPWR VPWR _4520_/A0 sky130_fd_sc_hd__dlygate4sd3_1
Xhold1149 _7164_/Q VGND VGND VPWR VPWR _5333_/A0 sky130_fd_sc_hd__dlygate4sd3_1
X_5024_ _4799_/A _3832_/X _5015_/X _5023_/Y VGND VGND VPWR VPWR _5024_/X sky130_fd_sc_hd__a211o_2
XFILLER_38_353 VGND VGND VPWR VPWR sky130_fd_sc_hd__decap_3
XFILLER_53_323 VGND VGND VPWR VPWR sky130_fd_sc_hd__decap_3
XFILLER_65_172 VGND VGND VPWR VPWR sky130_fd_sc_hd__decap_3
XFILLER_81_632 VGND VGND VPWR VPWR sky130_fd_sc_hd__decap_3
XFILLER_80_131 VGND VGND VPWR VPWR sky130_fd_sc_hd__decap_3
X_6975_ clkload1/A _6975_/D VGND VGND VPWR VPWR _6975_/Q sky130_fd_sc_hd__dfxtp_2
XFILLER_81_676 VGND VGND VPWR VPWR sky130_fd_sc_hd__decap_3
XFILLER_110_58 VGND VGND VPWR VPWR sky130_fd_sc_hd__decap_3
XFILLER_80_197 VGND VGND VPWR VPWR sky130_fd_sc_hd__fill_1
XFILLER_21_231 VGND VGND VPWR VPWR sky130_fd_sc_hd__decap_3
XFILLER_21_264 VGND VGND VPWR VPWR sky130_fd_sc_hd__decap_3
XFILLER_70_29 VGND VGND VPWR VPWR sky130_fd_sc_hd__decap_3
X_4739_ _4762_/A _4762_/B _4765_/B _4610_/A VGND VGND VPWR VPWR _4739_/Y sky130_fd_sc_hd__a211oi_2
XFILLER_107_325 VGND VGND VPWR VPWR sky130_fd_sc_hd__fill_2
XFILLER_107_358 VGND VGND VPWR VPWR sky130_fd_sc_hd__decap_3
X_6409_ _6540_/A VGND VGND VPWR VPWR _6409_/Y sky130_fd_sc_hd__inv_2
XTAP_TAPCELL_ROW_112_1601 VGND VPWR sky130_fd_sc_hd__tapvpwrvgnd_1
X_7389_ _7394_/CLK _7389_/D _6669_/Y VGND VGND VPWR VPWR _7389_/Q sky130_fd_sc_hd__dfrtp_2
Xhold972 _7188_/Q VGND VGND VPWR VPWR hold972/X sky130_fd_sc_hd__dlygate4sd3_1
Xhold961 _7380_/Q VGND VGND VPWR VPWR hold961/X sky130_fd_sc_hd__dlygate4sd3_1
Xhold950 _7036_/Q VGND VGND VPWR VPWR hold950/X sky130_fd_sc_hd__dlygate4sd3_1
XFILLER_0_113 VGND VGND VPWR VPWR sky130_fd_sc_hd__decap_3
XFILLER_103_520 VGND VGND VPWR VPWR sky130_fd_sc_hd__decap_3
XFILLER_88_220 VGND VGND VPWR VPWR sky130_fd_sc_hd__decap_3
Xhold994 _7199_/Q VGND VGND VPWR VPWR hold994/X sky130_fd_sc_hd__dlygate4sd3_1
Xhold983 _7377_/Q VGND VGND VPWR VPWR hold983/X sky130_fd_sc_hd__dlygate4sd3_1
XFILLER_88_253 VGND VGND VPWR VPWR sky130_fd_sc_hd__decap_3
XFILLER_95_15 VGND VGND VPWR VPWR sky130_fd_sc_hd__decap_3
XFILLER_48_128 VGND VGND VPWR VPWR sky130_fd_sc_hd__decap_3
XFILLER_28_53 VGND VGND VPWR VPWR sky130_fd_sc_hd__decap_3
XFILLER_28_75 VGND VGND VPWR VPWR sky130_fd_sc_hd__decap_3
XTAP_TAPCELL_ROW_47_819 VGND VPWR sky130_fd_sc_hd__tapvpwrvgnd_1
XFILLER_29_386 VGND VGND VPWR VPWR sky130_fd_sc_hd__decap_3
XFILLER_44_312 VGND VGND VPWR VPWR sky130_fd_sc_hd__decap_3
XFILLER_56_150 VGND VGND VPWR VPWR sky130_fd_sc_hd__decap_3
XFILLER_56_183 VGND VGND VPWR VPWR sky130_fd_sc_hd__decap_3
XFILLER_84_492 VGND VGND VPWR VPWR sky130_fd_sc_hd__decap_3
XFILLER_44_345 VGND VGND VPWR VPWR sky130_fd_sc_hd__decap_3
XFILLER_71_120 VGND VGND VPWR VPWR sky130_fd_sc_hd__decap_3
XPHY_EDGE_ROW_88_Left_205 VGND VGND VPWR VPWR sky130_fd_sc_hd__decap_3
XFILLER_44_41 VGND VGND VPWR VPWR sky130_fd_sc_hd__decap_3
XFILLER_44_52 VGND VGND VPWR VPWR sky130_fd_sc_hd__decap_3
XTAP_TAPCELL_ROW_27_576 VGND VPWR sky130_fd_sc_hd__tapvpwrvgnd_1
XFILLER_44_85 VGND VGND VPWR VPWR sky130_fd_sc_hd__fill_1
XFILLER_12_231 VGND VGND VPWR VPWR sky130_fd_sc_hd__decap_3
XFILLER_12_253 VGND VGND VPWR VPWR sky130_fd_sc_hd__decap_3
XFILLER_100_91 VGND VGND VPWR VPWR sky130_fd_sc_hd__decap_3
XFILLER_12_286 VGND VGND VPWR VPWR sky130_fd_sc_hd__decap_3
XFILLER_8_235 VGND VGND VPWR VPWR sky130_fd_sc_hd__decap_3
XFILLER_60_73 VGND VGND VPWR VPWR sky130_fd_sc_hd__decap_3
XFILLER_8_268 VGND VGND VPWR VPWR sky130_fd_sc_hd__decap_3
XPHY_EDGE_ROW_97_Left_214 VGND VGND VPWR VPWR sky130_fd_sc_hd__decap_3
XFILLER_5_24 VGND VGND VPWR VPWR sky130_fd_sc_hd__decap_3
XFILLER_113_317 VGND VGND VPWR VPWR sky130_fd_sc_hd__decap_3
XFILLER_5_57 VGND VGND VPWR VPWR sky130_fd_sc_hd__decap_3
XTAP_TAPCELL_ROW_74_1139 VGND VPWR sky130_fd_sc_hd__tapvpwrvgnd_1
XFILLER_99_529 VGND VGND VPWR VPWR sky130_fd_sc_hd__decap_3
XFILLER_106_380 VGND VGND VPWR VPWR sky130_fd_sc_hd__decap_3
XFILLER_69_60 VGND VGND VPWR VPWR sky130_fd_sc_hd__decap_3
XFILLER_69_93 VGND VGND VPWR VPWR sky130_fd_sc_hd__decap_3
XFILLER_79_242 VGND VGND VPWR VPWR sky130_fd_sc_hd__decap_3
XFILLER_79_275 VGND VGND VPWR VPWR sky130_fd_sc_hd__decap_3
XFILLER_39_128 VGND VGND VPWR VPWR sky130_fd_sc_hd__decap_3
XFILLER_94_212 VGND VGND VPWR VPWR sky130_fd_sc_hd__decap_3
XFILLER_54_109 VGND VGND VPWR VPWR sky130_fd_sc_hd__decap_3
XFILLER_94_256 VGND VGND VPWR VPWR sky130_fd_sc_hd__decap_3
XFILLER_47_161 VGND VGND VPWR VPWR sky130_fd_sc_hd__decap_3
XFILLER_47_172 VGND VGND VPWR VPWR sky130_fd_sc_hd__decap_3
XFILLER_75_470 VGND VGND VPWR VPWR sky130_fd_sc_hd__decap_3
XFILLER_85_81 VGND VGND VPWR VPWR sky130_fd_sc_hd__decap_3
XFILLER_62_131 VGND VGND VPWR VPWR sky130_fd_sc_hd__decap_3
XFILLER_90_440 VGND VGND VPWR VPWR sky130_fd_sc_hd__decap_3
XFILLER_50_315 VGND VGND VPWR VPWR sky130_fd_sc_hd__decap_3
XFILLER_62_175 VGND VGND VPWR VPWR sky130_fd_sc_hd__decap_3
XFILLER_63_676 VGND VGND VPWR VPWR sky130_fd_sc_hd__decap_3
XFILLER_90_473 VGND VGND VPWR VPWR sky130_fd_sc_hd__decap_3
X_6760_ _6965_/CLK _6760_/D VGND VGND VPWR VPWR _6760_/Q sky130_fd_sc_hd__dfxtp_2
XTAP_TAPCELL_ROW_85_1268 VGND VPWR sky130_fd_sc_hd__tapvpwrvgnd_1
XFILLER_16_592 VGND VGND VPWR VPWR sky130_fd_sc_hd__fill_1
XFILLER_50_348 VGND VGND VPWR VPWR sky130_fd_sc_hd__decap_3
X_6691_ _7384_/CLK _6691_/D VGND VGND VPWR VPWR _6691_/Q sky130_fd_sc_hd__dfxtp_2
X_5642_ _5642_/A _5642_/B VGND VGND VPWR VPWR _5643_/A sky130_fd_sc_hd__or2_2
X_5573_ hold984/X _4664_/A _4975_/Y VGND VGND VPWR VPWR _7044_/D sky130_fd_sc_hd__o21a_2
XFILLER_116_100 VGND VGND VPWR VPWR sky130_fd_sc_hd__decap_3
X_7312_ clkload3/A _7312_/D _6592_/Y VGND VGND VPWR VPWR _7312_/Q sky130_fd_sc_hd__dfrtp_2
X_4524_ _4524_/A0 _7285_/Q _4530_/S VGND VGND VPWR VPWR _7317_/D sky130_fd_sc_hd__mux2_2
XFILLER_116_144 VGND VGND VPWR VPWR sky130_fd_sc_hd__fill_2
XFILLER_7_290 VGND VGND VPWR VPWR sky130_fd_sc_hd__decap_3
X_7243_ _7371_/CLK _7243_/D _6523_/Y VGND VGND VPWR VPWR _7243_/Q sky130_fd_sc_hd__dfrtp_2
X_4455_ _4745_/A _4081_/X _4082_/X _4454_/X VGND VGND VPWR VPWR _4720_/B sky130_fd_sc_hd__o211a_2
XFILLER_104_339 VGND VGND VPWR VPWR sky130_fd_sc_hd__decap_3
X_7174_ _7393_/CLK _7174_/D _6454_/Y VGND VGND VPWR VPWR _7174_/Q sky130_fd_sc_hd__dfrtp_2
X_4386_ _7305_/Q _4488_/S _4437_/B1 _7369_/Q _4429_/C1 VGND VGND VPWR VPWR _4386_/X
+ sky130_fd_sc_hd__a221o_2
X_3406_ _3409_/D VGND VGND VPWR VPWR _3417_/C sky130_fd_sc_hd__inv_4
XFILLER_98_551 VGND VGND VPWR VPWR sky130_fd_sc_hd__decap_3
XFILLER_105_14 VGND VGND VPWR VPWR sky130_fd_sc_hd__fill_2
XFILLER_112_350 VGND VGND VPWR VPWR sky130_fd_sc_hd__decap_3
XFILLER_58_415 VGND VGND VPWR VPWR sky130_fd_sc_hd__decap_3
XFILLER_98_584 VGND VGND VPWR VPWR sky130_fd_sc_hd__decap_3
XFILLER_100_512 VGND VGND VPWR VPWR sky130_fd_sc_hd__decap_3
XFILLER_105_25 VGND VGND VPWR VPWR sky130_fd_sc_hd__decap_3
XFILLER_105_47 VGND VGND VPWR VPWR sky130_fd_sc_hd__decap_3
XFILLER_112_383 VGND VGND VPWR VPWR sky130_fd_sc_hd__decap_3
XFILLER_58_448 VGND VGND VPWR VPWR sky130_fd_sc_hd__decap_3
XFILLER_85_212 VGND VGND VPWR VPWR sky130_fd_sc_hd__decap_3
XFILLER_85_234 VGND VGND VPWR VPWR sky130_fd_sc_hd__decap_3
XFILLER_105_69 VGND VGND VPWR VPWR sky130_fd_sc_hd__decap_3
XFILLER_65_29 VGND VGND VPWR VPWR sky130_fd_sc_hd__decap_3
XFILLER_73_407 VGND VGND VPWR VPWR sky130_fd_sc_hd__decap_3
XFILLER_26_312 VGND VGND VPWR VPWR sky130_fd_sc_hd__decap_3
XFILLER_38_150 VGND VGND VPWR VPWR sky130_fd_sc_hd__decap_3
X_5007_ _5002_/Y _5003_/X _5004_/X _5005_/Y _5006_/X VGND VGND VPWR VPWR _5662_/A
+ sky130_fd_sc_hd__a221o_2
XFILLER_38_183 VGND VGND VPWR VPWR sky130_fd_sc_hd__decap_3
XFILLER_54_643 VGND VGND VPWR VPWR sky130_fd_sc_hd__fill_1
XFILLER_66_492 VGND VGND VPWR VPWR sky130_fd_sc_hd__decap_3
XFILLER_81_440 VGND VGND VPWR VPWR sky130_fd_sc_hd__decap_3
XFILLER_14_529 VGND VGND VPWR VPWR sky130_fd_sc_hd__decap_3
XFILLER_26_389 VGND VGND VPWR VPWR sky130_fd_sc_hd__decap_3
XFILLER_53_142 VGND VGND VPWR VPWR sky130_fd_sc_hd__fill_2
XFILLER_53_164 VGND VGND VPWR VPWR sky130_fd_sc_hd__decap_3
XFILLER_53_175 VGND VGND VPWR VPWR sky130_fd_sc_hd__decap_3
XFILLER_81_473 VGND VGND VPWR VPWR sky130_fd_sc_hd__decap_3
XFILLER_41_337 VGND VGND VPWR VPWR sky130_fd_sc_hd__decap_3
XFILLER_53_186 VGND VGND VPWR VPWR sky130_fd_sc_hd__decap_3
XFILLER_81_28 VGND VGND VPWR VPWR sky130_fd_sc_hd__decap_3
X_6958_ _6972_/CLK _6958_/D VGND VGND VPWR VPWR _6958_/Q sky130_fd_sc_hd__dfxtp_2
XTAP_TAPCELL_ROW_24_535 VGND VPWR sky130_fd_sc_hd__tapvpwrvgnd_1
X_6889_ _6966_/CLK _6889_/D VGND VGND VPWR VPWR _6889_/Q sky130_fd_sc_hd__dfxtp_2
XTAP_TAPCELL_ROW_52_877 VGND VPWR sky130_fd_sc_hd__tapvpwrvgnd_1
XFILLER_22_573 VGND VGND VPWR VPWR sky130_fd_sc_hd__decap_3
XFILLER_108_601 VGND VGND VPWR VPWR sky130_fd_sc_hd__decap_3
XFILLER_14_88 VGND VGND VPWR VPWR sky130_fd_sc_hd__decap_3
XFILLER_5_205 VGND VGND VPWR VPWR sky130_fd_sc_hd__decap_3
XFILLER_108_656 VGND VGND VPWR VPWR sky130_fd_sc_hd__decap_3
XFILLER_100_3 VGND VGND VPWR VPWR sky130_fd_sc_hd__decap_3
XFILLER_108_689 VGND VGND VPWR VPWR sky130_fd_sc_hd__decap_3
XFILLER_107_199 VGND VGND VPWR VPWR sky130_fd_sc_hd__decap_3
XFILLER_89_540 VGND VGND VPWR VPWR sky130_fd_sc_hd__decap_3
Xhold780 _6924_/Q VGND VGND VPWR VPWR _6924_/D sky130_fd_sc_hd__dlygate4sd3_1
Xhold791 _6781_/Q VGND VGND VPWR VPWR _6781_/D sky130_fd_sc_hd__dlygate4sd3_1
XFILLER_103_361 VGND VGND VPWR VPWR sky130_fd_sc_hd__decap_3
XFILLER_110_309 VGND VGND VPWR VPWR sky130_fd_sc_hd__decap_3
XFILLER_39_30 VGND VGND VPWR VPWR sky130_fd_sc_hd__decap_3
XFILLER_49_404 VGND VGND VPWR VPWR sky130_fd_sc_hd__decap_3
XFILLER_49_437 VGND VGND VPWR VPWR sky130_fd_sc_hd__fill_2
XFILLER_76_223 VGND VGND VPWR VPWR sky130_fd_sc_hd__decap_3
XFILLER_76_267 VGND VGND VPWR VPWR sky130_fd_sc_hd__decap_3
XFILLER_29_161 VGND VGND VPWR VPWR sky130_fd_sc_hd__decap_3
XFILLER_29_172 VGND VGND VPWR VPWR sky130_fd_sc_hd__decap_3
XFILLER_64_418 VGND VGND VPWR VPWR sky130_fd_sc_hd__fill_2
XFILLER_91_204 VGND VGND VPWR VPWR sky130_fd_sc_hd__decap_3
XFILLER_17_323 VGND VGND VPWR VPWR sky130_fd_sc_hd__decap_3
XFILLER_44_131 VGND VGND VPWR VPWR sky130_fd_sc_hd__decap_3
XFILLER_91_237 VGND VGND VPWR VPWR sky130_fd_sc_hd__fill_1
XFILLER_91_259 VGND VGND VPWR VPWR sky130_fd_sc_hd__decap_3
XFILLER_17_367 VGND VGND VPWR VPWR sky130_fd_sc_hd__decap_3
XFILLER_17_389 VGND VGND VPWR VPWR sky130_fd_sc_hd__decap_3
XFILLER_72_451 VGND VGND VPWR VPWR sky130_fd_sc_hd__decap_3
XFILLER_32_326 VGND VGND VPWR VPWR sky130_fd_sc_hd__decap_3
XFILLER_32_337 VGND VGND VPWR VPWR sky130_fd_sc_hd__fill_1
XFILLER_44_175 VGND VGND VPWR VPWR sky130_fd_sc_hd__decap_3
XFILLER_44_197 VGND VGND VPWR VPWR sky130_fd_sc_hd__decap_3
XFILLER_111_90 VGND VGND VPWR VPWR sky130_fd_sc_hd__decap_3
XFILLER_13_551 VGND VGND VPWR VPWR sky130_fd_sc_hd__fill_1
XFILLER_71_72 VGND VGND VPWR VPWR sky130_fd_sc_hd__decap_3
XFILLER_71_94 VGND VGND VPWR VPWR sky130_fd_sc_hd__decap_3
XFILLER_9_555 VGND VGND VPWR VPWR sky130_fd_sc_hd__decap_3
XFILLER_65_6 VGND VGND VPWR VPWR sky130_fd_sc_hd__decap_3
XFILLER_9_588 VGND VGND VPWR VPWR sky130_fd_sc_hd__decap_3
XFILLER_99_326 VGND VGND VPWR VPWR sky130_fd_sc_hd__decap_3
XFILLER_113_136 VGND VGND VPWR VPWR sky130_fd_sc_hd__decap_3
XFILLER_4_282 VGND VGND VPWR VPWR sky130_fd_sc_hd__decap_3
X_4240_ _4628_/A _4629_/B VGND VGND VPWR VPWR _4241_/B sky130_fd_sc_hd__and2_2
XFILLER_99_337 VGND VGND VPWR VPWR sky130_fd_sc_hd__decap_3
XFILLER_113_169 VGND VGND VPWR VPWR sky130_fd_sc_hd__decap_3
X_4171_ _4203_/A _4203_/B _4202_/A VGND VGND VPWR VPWR _4379_/B sky130_fd_sc_hd__a21oi_2
XFILLER_67_234 VGND VGND VPWR VPWR sky130_fd_sc_hd__decap_3
XFILLER_95_532 VGND VGND VPWR VPWR sky130_fd_sc_hd__decap_3
XFILLER_96_80 VGND VGND VPWR VPWR sky130_fd_sc_hd__decap_3
XFILLER_36_610 VGND VGND VPWR VPWR sky130_fd_sc_hd__decap_3
XFILLER_55_418 VGND VGND VPWR VPWR sky130_fd_sc_hd__decap_3
XFILLER_35_131 VGND VGND VPWR VPWR sky130_fd_sc_hd__decap_3
XFILLER_82_259 VGND VGND VPWR VPWR sky130_fd_sc_hd__decap_3
XFILLER_23_304 VGND VGND VPWR VPWR sky130_fd_sc_hd__decap_3
Xplace440 _5156_/S VGND VGND VPWR VPWR _4836_/S sky130_fd_sc_hd__buf_2
X_6812_ _6972_/CLK _6812_/D VGND VGND VPWR VPWR _6812_/Q sky130_fd_sc_hd__dfxtp_2
XFILLER_35_186 VGND VGND VPWR VPWR sky130_fd_sc_hd__decap_3
XFILLER_63_495 VGND VGND VPWR VPWR sky130_fd_sc_hd__decap_3
XFILLER_90_292 VGND VGND VPWR VPWR sky130_fd_sc_hd__decap_3
Xplace451 _4469_/A3 VGND VGND VPWR VPWR _4414_/A2 sky130_fd_sc_hd__buf_2
Xplace462 _6980_/Q VGND VGND VPWR VPWR _3353_/A sky130_fd_sc_hd__buf_2
XFILLER_50_156 VGND VGND VPWR VPWR sky130_fd_sc_hd__decap_3
X_6743_ _6965_/CLK _6743_/D VGND VGND VPWR VPWR _6743_/Q sky130_fd_sc_hd__dfxtp_2
XFILLER_50_189 VGND VGND VPWR VPWR sky130_fd_sc_hd__decap_3
X_6674_ _6674_/A VGND VGND VPWR VPWR _6674_/Y sky130_fd_sc_hd__inv_2
XTAP_TAPCELL_ROW_21_505 VGND VPWR sky130_fd_sc_hd__tapvpwrvgnd_1
X_3886_ _6920_/Q _3661_/X _3893_/A2 _6784_/Q VGND VGND VPWR VPWR _3886_/X sky130_fd_sc_hd__a22o_2
XTAP_TAPCELL_ROW_98_1426 VGND VPWR sky130_fd_sc_hd__tapvpwrvgnd_1
XFILLER_2_219 VGND VGND VPWR VPWR sky130_fd_sc_hd__decap_3
X_4507_ _4507_/A0 _7294_/Q _4507_/S VGND VGND VPWR VPWR _7326_/D sky130_fd_sc_hd__mux2_2
XFILLER_104_114 VGND VGND VPWR VPWR sky130_fd_sc_hd__fill_2
X_7226_ _7394_/CLK _7226_/D _6506_/Y VGND VGND VPWR VPWR _7226_/Q sky130_fd_sc_hd__dfrtp_2
X_4438_ _4434_/X _4437_/X _4425_/A VGND VGND VPWR VPWR _4650_/B sky130_fd_sc_hd__o21a_2
XFILLER_104_158 VGND VGND VPWR VPWR sky130_fd_sc_hd__decap_3
XFILLER_116_35 VGND VGND VPWR VPWR sky130_fd_sc_hd__decap_3
XFILLER_116_68 VGND VGND VPWR VPWR sky130_fd_sc_hd__decap_3
XFILLER_58_212 VGND VGND VPWR VPWR sky130_fd_sc_hd__decap_3
X_7157_ clkload4/A _7157_/D _6437_/Y VGND VGND VPWR VPWR _7157_/Q sky130_fd_sc_hd__dfrtp_2
X_4369_ _4369_/A _4369_/B VGND VGND VPWR VPWR _4369_/Y sky130_fd_sc_hd__nor2_2
XFILLER_98_392 VGND VGND VPWR VPWR sky130_fd_sc_hd__decap_3
XFILLER_100_342 VGND VGND VPWR VPWR sky130_fd_sc_hd__decap_3
XFILLER_58_245 VGND VGND VPWR VPWR sky130_fd_sc_hd__decap_3
XFILLER_58_256 VGND VGND VPWR VPWR sky130_fd_sc_hd__fill_1
X_7088_ clkload8/A _7088_/D _6368_/Y VGND VGND VPWR VPWR _7088_/Q sky130_fd_sc_hd__dfrtp_2
XFILLER_100_386 VGND VGND VPWR VPWR sky130_fd_sc_hd__decap_3
XFILLER_73_204 VGND VGND VPWR VPWR sky130_fd_sc_hd__decap_3
XFILLER_73_215 VGND VGND VPWR VPWR sky130_fd_sc_hd__decap_3
XTAP_TAPCELL_ROW_57_936 VGND VPWR sky130_fd_sc_hd__tapvpwrvgnd_1
XTAP_TAPCELL_ROW_29_605 VGND VPWR sky130_fd_sc_hd__tapvpwrvgnd_1
XFILLER_73_237 VGND VGND VPWR VPWR sky130_fd_sc_hd__decap_3
XTAP_TAPCELL_ROW_107_1533 VGND VPWR sky130_fd_sc_hd__tapvpwrvgnd_1
XFILLER_26_153 VGND VGND VPWR VPWR sky130_fd_sc_hd__decap_3
XFILLER_54_451 VGND VGND VPWR VPWR sky130_fd_sc_hd__fill_1
XFILLER_54_462 VGND VGND VPWR VPWR sky130_fd_sc_hd__decap_3
XFILLER_92_38 VGND VGND VPWR VPWR sky130_fd_sc_hd__decap_3
XTAP_TAPCELL_ROW_1_263 VGND VPWR sky130_fd_sc_hd__tapvpwrvgnd_1
XFILLER_25_54 VGND VGND VPWR VPWR sky130_fd_sc_hd__fill_2
XFILLER_26_197 VGND VGND VPWR VPWR sky130_fd_sc_hd__decap_3
XFILLER_41_101 VGND VGND VPWR VPWR sky130_fd_sc_hd__decap_3
XFILLER_42_635 VGND VGND VPWR VPWR sky130_fd_sc_hd__fill_1
XFILLER_81_281 VGND VGND VPWR VPWR sky130_fd_sc_hd__decap_3
XTAP_TAPCELL_ROW_37_693 VGND VPWR sky130_fd_sc_hd__tapvpwrvgnd_1
XFILLER_25_87 VGND VGND VPWR VPWR sky130_fd_sc_hd__decap_3
XFILLER_41_134 VGND VGND VPWR VPWR sky130_fd_sc_hd__decap_3
XFILLER_41_156 VGND VGND VPWR VPWR sky130_fd_sc_hd__decap_3
XFILLER_41_167 VGND VGND VPWR VPWR sky130_fd_sc_hd__fill_1
XFILLER_41_178 VGND VGND VPWR VPWR sky130_fd_sc_hd__decap_3
XFILLER_22_392 VGND VGND VPWR VPWR sky130_fd_sc_hd__decap_3
XFILLER_41_20 VGND VGND VPWR VPWR sky130_fd_sc_hd__fill_1
XFILLER_50_690 VGND VGND VPWR VPWR sky130_fd_sc_hd__fill_2
XFILLER_41_42 VGND VGND VPWR VPWR sky130_fd_sc_hd__decap_3
XFILLER_41_75 VGND VGND VPWR VPWR sky130_fd_sc_hd__decap_3
XFILLER_6_514 VGND VGND VPWR VPWR sky130_fd_sc_hd__fill_1
XFILLER_6_536 VGND VGND VPWR VPWR sky130_fd_sc_hd__fill_2
XTAP_TAPCELL_ROW_71_1109 VGND VPWR sky130_fd_sc_hd__tapvpwrvgnd_1
XFILLER_96_307 VGND VGND VPWR VPWR sky130_fd_sc_hd__fill_1
XFILLER_96_318 VGND VGND VPWR VPWR sky130_fd_sc_hd__decap_3
XTAP_TAPCELL_ROW_9_363 VGND VPWR sky130_fd_sc_hd__tapvpwrvgnd_1
XFILLER_110_139 VGND VGND VPWR VPWR sky130_fd_sc_hd__fill_1
XFILLER_77_532 VGND VGND VPWR VPWR sky130_fd_sc_hd__decap_3
XFILLER_89_381 VGND VGND VPWR VPWR sky130_fd_sc_hd__decap_3
XFILLER_2_58 VGND VGND VPWR VPWR sky130_fd_sc_hd__decap_3
XFILLER_49_256 VGND VGND VPWR VPWR sky130_fd_sc_hd__decap_3
XFILLER_77_554 VGND VGND VPWR VPWR sky130_fd_sc_hd__decap_3
XFILLER_49_278 VGND VGND VPWR VPWR sky130_fd_sc_hd__fill_2
XFILLER_77_598 VGND VGND VPWR VPWR sky130_fd_sc_hd__decap_3
XFILLER_18_643 VGND VGND VPWR VPWR sky130_fd_sc_hd__fill_1
XFILLER_64_237 VGND VGND VPWR VPWR sky130_fd_sc_hd__decap_3
XFILLER_45_473 VGND VGND VPWR VPWR sky130_fd_sc_hd__decap_3
XFILLER_72_292 VGND VGND VPWR VPWR sky130_fd_sc_hd__decap_3
XTAP_TAPCELL_ROW_82_1238 VGND VPWR sky130_fd_sc_hd__tapvpwrvgnd_1
XFILLER_60_454 VGND VGND VPWR VPWR sky130_fd_sc_hd__decap_3
XFILLER_82_82 VGND VGND VPWR VPWR sky130_fd_sc_hd__fill_2
XANTENNA_19 _7363_/Q VGND VGND VPWR VPWR sky130_fd_sc_hd__diode_2
XFILLER_20_307 VGND VGND VPWR VPWR sky130_fd_sc_hd__fill_1
XFILLER_20_318 VGND VGND VPWR VPWR sky130_fd_sc_hd__decap_3
XFILLER_60_498 VGND VGND VPWR VPWR sky130_fd_sc_hd__decap_3
X_3740_ _6710_/Q _3826_/A2 _3827_/B1 _6888_/Q _3739_/X VGND VGND VPWR VPWR _3740_/X
+ sky130_fd_sc_hd__a221o_2
XFILLER_9_352 VGND VGND VPWR VPWR sky130_fd_sc_hd__decap_3
XFILLER_9_330 VGND VGND VPWR VPWR sky130_fd_sc_hd__decap_3
X_3671_ _3671_/A1 _4832_/A _3670_/X VGND VGND VPWR VPWR _7405_/D sky130_fd_sc_hd__o21a_2
XFILLER_63_3 VGND VGND VPWR VPWR sky130_fd_sc_hd__decap_3
X_6390_ _6616_/A VGND VGND VPWR VPWR _6390_/Y sky130_fd_sc_hd__inv_2
XFILLER_114_412 VGND VGND VPWR VPWR sky130_fd_sc_hd__decap_3
XTAP_TAPCELL_ROW_93_1367 VGND VPWR sky130_fd_sc_hd__tapvpwrvgnd_1
X_7011_ clkload6/A _7011_/D _6291_/Y VGND VGND VPWR VPWR _7011_/Q sky130_fd_sc_hd__dfrtp_2
X_5272_ _5272_/A0 _5061_/X _5274_/S VGND VGND VPWR VPWR _7194_/D sky130_fd_sc_hd__mux2_2
XFILLER_102_629 VGND VGND VPWR VPWR sky130_fd_sc_hd__decap_3
XFILLER_87_329 VGND VGND VPWR VPWR sky130_fd_sc_hd__decap_3
X_4223_ _4217_/X _4219_/X _4222_/X _4327_/A VGND VGND VPWR VPWR _4224_/C sky130_fd_sc_hd__o31a_2
XFILLER_110_651 VGND VGND VPWR VPWR sky130_fd_sc_hd__fill_1
XFILLER_68_554 VGND VGND VPWR VPWR sky130_fd_sc_hd__decap_3
XFILLER_95_340 VGND VGND VPWR VPWR sky130_fd_sc_hd__decap_3
X_4154_ _7047_/Q _4486_/S _4437_/B1 _7394_/Q _4153_/X VGND VGND VPWR VPWR _4154_/X
+ sky130_fd_sc_hd__a221o_2
XFILLER_110_673 VGND VGND VPWR VPWR sky130_fd_sc_hd__fill_1
XFILLER_28_418 VGND VGND VPWR VPWR sky130_fd_sc_hd__fill_2
XFILLER_55_204 VGND VGND VPWR VPWR sky130_fd_sc_hd__decap_3
XFILLER_68_587 VGND VGND VPWR VPWR sky130_fd_sc_hd__fill_1
XFILLER_68_598 VGND VGND VPWR VPWR sky130_fd_sc_hd__decap_3
XFILLER_95_384 VGND VGND VPWR VPWR sky130_fd_sc_hd__decap_3
X_4085_ _7238_/Q _4430_/A2 _5229_/C _7142_/Q _4084_/X VGND VGND VPWR VPWR _4085_/X
+ sky130_fd_sc_hd__a221o_2
XFILLER_55_237 VGND VGND VPWR VPWR sky130_fd_sc_hd__decap_3
XFILLER_102_37 VGND VGND VPWR VPWR sky130_fd_sc_hd__decap_3
XFILLER_83_579 VGND VGND VPWR VPWR sky130_fd_sc_hd__decap_3
XFILLER_36_473 VGND VGND VPWR VPWR sky130_fd_sc_hd__decap_3
XFILLER_63_281 VGND VGND VPWR VPWR sky130_fd_sc_hd__decap_3
XFILLER_70_229 VGND VGND VPWR VPWR sky130_fd_sc_hd__decap_3
XFILLER_51_443 VGND VGND VPWR VPWR sky130_fd_sc_hd__decap_3
Xplace281 _3892_/A2 VGND VGND VPWR VPWR _3912_/A2 sky130_fd_sc_hd__buf_2
Xplace270 _3892_/B1 VGND VGND VPWR VPWR _3925_/B1 sky130_fd_sc_hd__buf_2
XFILLER_23_178 VGND VGND VPWR VPWR sky130_fd_sc_hd__decap_3
XFILLER_51_476 VGND VGND VPWR VPWR sky130_fd_sc_hd__fill_1
Xplace292 _3890_/B1 VGND VGND VPWR VPWR _5660_/B sky130_fd_sc_hd__buf_2
X_6726_ _6976_/CLK _6726_/D VGND VGND VPWR VPWR _6726_/Q sky130_fd_sc_hd__dfxtp_2
X_4987_ _4987_/A _4987_/B VGND VGND VPWR VPWR _4987_/Y sky130_fd_sc_hd__xnor2_2
XTAP_TAPCELL_ROW_62_994 VGND VPWR sky130_fd_sc_hd__tapvpwrvgnd_1
XTAP_TAPCELL_ROW_34_663 VGND VPWR sky130_fd_sc_hd__tapvpwrvgnd_1
XFILLER_32_690 VGND VGND VPWR VPWR sky130_fd_sc_hd__fill_2
XTAP_TAPCELL_ROW_102_1474 VGND VPWR sky130_fd_sc_hd__tapvpwrvgnd_1
XFILLER_109_206 VGND VGND VPWR VPWR sky130_fd_sc_hd__decap_3
X_6657_ _6660_/A VGND VGND VPWR VPWR _6657_/Y sky130_fd_sc_hd__inv_2
X_3869_ _6772_/Q _3869_/A2 _3912_/B1 _6766_/Q VGND VGND VPWR VPWR _3869_/X sky130_fd_sc_hd__a22o_2
X_6588_ _6651_/A VGND VGND VPWR VPWR _6588_/Y sky130_fd_sc_hd__inv_2
XFILLER_105_445 VGND VGND VPWR VPWR sky130_fd_sc_hd__decap_3
XFILLER_11_78 VGND VGND VPWR VPWR sky130_fd_sc_hd__decap_3
XFILLER_105_467 VGND VGND VPWR VPWR sky130_fd_sc_hd__decap_3
XFILLER_78_318 VGND VGND VPWR VPWR sky130_fd_sc_hd__decap_3
XFILLER_87_27 VGND VGND VPWR VPWR sky130_fd_sc_hd__decap_3
XPHY_EDGE_ROW_52_Left_169 VGND VGND VPWR VPWR sky130_fd_sc_hd__decap_3
X_7209_ _7307_/CLK _7209_/D _6489_/Y VGND VGND VPWR VPWR _7209_/Q sky130_fd_sc_hd__dfrtp_2
XTAP_TAPCELL_ROW_6_322 VGND VPWR sky130_fd_sc_hd__tapvpwrvgnd_1
XFILLER_100_150 VGND VGND VPWR VPWR sky130_fd_sc_hd__decap_3
XFILLER_19_429 VGND VGND VPWR VPWR sky130_fd_sc_hd__decap_3
XFILLER_46_215 VGND VGND VPWR VPWR sky130_fd_sc_hd__decap_3
XFILLER_74_502 VGND VGND VPWR VPWR sky130_fd_sc_hd__decap_3
XFILLER_86_351 VGND VGND VPWR VPWR sky130_fd_sc_hd__decap_3
XFILLER_74_557 VGND VGND VPWR VPWR sky130_fd_sc_hd__decap_3
XFILLER_86_395 VGND VGND VPWR VPWR sky130_fd_sc_hd__decap_3
XFILLER_36_53 VGND VGND VPWR VPWR sky130_fd_sc_hd__decap_3
XFILLER_46_259 VGND VGND VPWR VPWR sky130_fd_sc_hd__fill_2
XFILLER_54_281 VGND VGND VPWR VPWR sky130_fd_sc_hd__decap_3
XTAP_TAPCELL_ROW_68_1071 VGND VPWR sky130_fd_sc_hd__tapvpwrvgnd_1
XPHY_EDGE_ROW_61_Left_178 VGND VGND VPWR VPWR sky130_fd_sc_hd__decap_3
XFILLER_42_454 VGND VGND VPWR VPWR sky130_fd_sc_hd__fill_1
XFILLER_52_41 VGND VGND VPWR VPWR sky130_fd_sc_hd__fill_1
XFILLER_23_690 VGND VGND VPWR VPWR sky130_fd_sc_hd__fill_2
XFILLER_52_52 VGND VGND VPWR VPWR sky130_fd_sc_hd__decap_3
XFILLER_52_74 VGND VGND VPWR VPWR sky130_fd_sc_hd__decap_3
XFILLER_10_351 VGND VGND VPWR VPWR sky130_fd_sc_hd__decap_3
XFILLER_6_300 VGND VGND VPWR VPWR sky130_fd_sc_hd__decap_3
XFILLER_6_344 VGND VGND VPWR VPWR sky130_fd_sc_hd__decap_3
XFILLER_6_377 VGND VGND VPWR VPWR sky130_fd_sc_hd__decap_3
XPHY_EDGE_ROW_70_Left_187 VGND VGND VPWR VPWR sky130_fd_sc_hd__decap_3
XFILLER_6_399 VGND VGND VPWR VPWR sky130_fd_sc_hd__decap_3
XFILLER_96_115 VGND VGND VPWR VPWR sky130_fd_sc_hd__decap_3
XFILLER_97_638 VGND VGND VPWR VPWR sky130_fd_sc_hd__decap_3
XFILLER_28_6 VGND VGND VPWR VPWR sky130_fd_sc_hd__decap_3
XFILLER_77_340 VGND VGND VPWR VPWR sky130_fd_sc_hd__decap_3
XFILLER_77_60 VGND VGND VPWR VPWR sky130_fd_sc_hd__decap_3
XFILLER_96_159 VGND VGND VPWR VPWR sky130_fd_sc_hd__decap_3
XFILLER_37_215 VGND VGND VPWR VPWR sky130_fd_sc_hd__decap_3
XFILLER_77_373 VGND VGND VPWR VPWR sky130_fd_sc_hd__decap_3
XFILLER_37_237 VGND VGND VPWR VPWR sky130_fd_sc_hd__decap_3
XFILLER_92_321 VGND VGND VPWR VPWR sky130_fd_sc_hd__decap_3
XFILLER_80_516 VGND VGND VPWR VPWR sky130_fd_sc_hd__decap_3
XFILLER_92_365 VGND VGND VPWR VPWR sky130_fd_sc_hd__decap_3
XFILLER_92_398 VGND VGND VPWR VPWR sky130_fd_sc_hd__decap_3
X_4910_ _5092_/C _4910_/B VGND VGND VPWR VPWR _4910_/Y sky130_fd_sc_hd__nand2_2
X_4841_ _4890_/B _4888_/B VGND VGND VPWR VPWR _4841_/Y sky130_fd_sc_hd__nand2b_2
XFILLER_60_262 VGND VGND VPWR VPWR sky130_fd_sc_hd__decap_3
XFILLER_20_126 VGND VGND VPWR VPWR sky130_fd_sc_hd__decap_3
XFILLER_60_295 VGND VGND VPWR VPWR sky130_fd_sc_hd__decap_3
X_4772_ _4772_/A0 _4771_/X _4793_/S VGND VGND VPWR VPWR _7275_/D sky130_fd_sc_hd__mux2_2
XTAP_TAPCELL_ROW_31_622 VGND VPWR sky130_fd_sc_hd__tapvpwrvgnd_1
X_6511_ _6548_/A VGND VGND VPWR VPWR _6511_/Y sky130_fd_sc_hd__inv_2
X_3723_ _6813_/Q _3889_/B1 _3888_/B1 _6823_/Q VGND VGND VPWR VPWR _3723_/X sky130_fd_sc_hd__a22o_2
X_6442_ _6535_/A VGND VGND VPWR VPWR _6442_/Y sky130_fd_sc_hd__inv_2
XFILLER_9_193 VGND VGND VPWR VPWR sky130_fd_sc_hd__decap_3
XFILLER_106_209 VGND VGND VPWR VPWR sky130_fd_sc_hd__decap_3
X_6373_ _6567_/A VGND VGND VPWR VPWR _6373_/Y sky130_fd_sc_hd__inv_2
X_3585_ _3591_/A _3591_/B _3591_/C _3586_/D VGND VGND VPWR VPWR _3599_/A sky130_fd_sc_hd__o31a_2
XFILLER_88_605 VGND VGND VPWR VPWR sky130_fd_sc_hd__decap_3
XFILLER_114_264 VGND VGND VPWR VPWR sky130_fd_sc_hd__decap_3
XFILLER_87_126 VGND VGND VPWR VPWR sky130_fd_sc_hd__decap_3
XFILLER_87_137 VGND VGND VPWR VPWR sky130_fd_sc_hd__decap_3
XFILLER_87_159 VGND VGND VPWR VPWR sky130_fd_sc_hd__decap_3
X_4206_ _4920_/A _4204_/Y _4205_/X VGND VGND VPWR VPWR _4206_/X sky130_fd_sc_hd__a21o_2
XFILLER_56_513 VGND VGND VPWR VPWR sky130_fd_sc_hd__decap_3
XFILLER_68_362 VGND VGND VPWR VPWR sky130_fd_sc_hd__fill_2
X_5186_ _5186_/A _5194_/B VGND VGND VPWR VPWR _7235_/D sky130_fd_sc_hd__and2_2
XFILLER_113_14 VGND VGND VPWR VPWR sky130_fd_sc_hd__decap_3
XFILLER_28_215 VGND VGND VPWR VPWR sky130_fd_sc_hd__decap_3
XFILLER_56_546 VGND VGND VPWR VPWR sky130_fd_sc_hd__fill_1
XFILLER_68_395 VGND VGND VPWR VPWR sky130_fd_sc_hd__fill_2
XFILLER_83_321 VGND VGND VPWR VPWR sky130_fd_sc_hd__decap_3
XFILLER_95_181 VGND VGND VPWR VPWR sky130_fd_sc_hd__decap_3
X_4137_ _7048_/Q _4501_/S _4196_/A2 _7395_/Q _4136_/X VGND VGND VPWR VPWR _4137_/X
+ sky130_fd_sc_hd__a221o_2
XTAP_TAPCELL_ROW_39_722 VGND VPWR sky130_fd_sc_hd__tapvpwrvgnd_1
XFILLER_28_259 VGND VGND VPWR VPWR sky130_fd_sc_hd__decap_3
XFILLER_71_505 VGND VGND VPWR VPWR sky130_fd_sc_hd__decap_3
XFILLER_83_376 VGND VGND VPWR VPWR sky130_fd_sc_hd__decap_3
X_4068_ _4068_/A _4082_/A VGND VGND VPWR VPWR _4069_/B sky130_fd_sc_hd__nor2_2
XFILLER_24_421 VGND VGND VPWR VPWR sky130_fd_sc_hd__decap_3
XFILLER_36_270 VGND VGND VPWR VPWR sky130_fd_sc_hd__decap_3
XFILLER_43_218 VGND VGND VPWR VPWR sky130_fd_sc_hd__decap_3
XFILLER_71_549 VGND VGND VPWR VPWR sky130_fd_sc_hd__decap_3
XTAP_TAPCELL_ROW_104_1503 VGND VPWR sky130_fd_sc_hd__tapvpwrvgnd_1
XFILLER_24_454 VGND VGND VPWR VPWR sky130_fd_sc_hd__fill_1
XFILLER_51_240 VGND VGND VPWR VPWR sky130_fd_sc_hd__fill_1
XFILLER_11_137 VGND VGND VPWR VPWR sky130_fd_sc_hd__decap_3
XFILLER_51_284 VGND VGND VPWR VPWR sky130_fd_sc_hd__decap_3
X_6709_ _7406_/CLK _6709_/D VGND VGND VPWR VPWR _6709_/Q sky130_fd_sc_hd__dfxtp_2
XFILLER_22_44 VGND VGND VPWR VPWR sky130_fd_sc_hd__decap_3
XFILLER_22_77 VGND VGND VPWR VPWR sky130_fd_sc_hd__decap_3
XFILLER_105_220 VGND VGND VPWR VPWR sky130_fd_sc_hd__decap_3
XTAP_TAPCELL_ROW_115_1632 VGND VPWR sky130_fd_sc_hd__tapvpwrvgnd_1
XFILLER_98_48 VGND VGND VPWR VPWR sky130_fd_sc_hd__decap_3
XFILLER_105_231 VGND VGND VPWR VPWR sky130_fd_sc_hd__decap_3
XFILLER_3_369 VGND VGND VPWR VPWR sky130_fd_sc_hd__decap_3
XFILLER_105_275 VGND VGND VPWR VPWR sky130_fd_sc_hd__decap_3
XFILLER_79_638 VGND VGND VPWR VPWR sky130_fd_sc_hd__decap_3
Xoutput490 _3640_/X VGND VGND VPWR VPWR alu_result_out[3] sky130_fd_sc_hd__clkdlybuf4s25_1
XFILLER_87_671 VGND VGND VPWR VPWR sky130_fd_sc_hd__fill_1
XFILLER_19_237 VGND VGND VPWR VPWR sky130_fd_sc_hd__decap_3
XFILLER_74_321 VGND VGND VPWR VPWR sky130_fd_sc_hd__decap_3
XFILLER_86_192 VGND VGND VPWR VPWR sky130_fd_sc_hd__decap_3
XFILLER_47_74 VGND VGND VPWR VPWR sky130_fd_sc_hd__decap_3
XFILLER_74_365 VGND VGND VPWR VPWR sky130_fd_sc_hd__decap_3
XFILLER_34_229 VGND VGND VPWR VPWR sky130_fd_sc_hd__fill_2
XFILLER_103_91 VGND VGND VPWR VPWR sky130_fd_sc_hd__decap_3
XFILLER_15_432 VGND VGND VPWR VPWR sky130_fd_sc_hd__decap_3
XFILLER_27_281 VGND VGND VPWR VPWR sky130_fd_sc_hd__fill_1
XFILLER_63_40 VGND VGND VPWR VPWR sky130_fd_sc_hd__fill_1
XFILLER_97_9 VGND VGND VPWR VPWR sky130_fd_sc_hd__decap_3
XFILLER_30_424 VGND VGND VPWR VPWR sky130_fd_sc_hd__decap_3
XFILLER_63_95 VGND VGND VPWR VPWR sky130_fd_sc_hd__decap_3
XFILLER_8_35 VGND VGND VPWR VPWR sky130_fd_sc_hd__fill_1
XFILLER_8_68 VGND VGND VPWR VPWR sky130_fd_sc_hd__decap_3
XFILLER_10_192 VGND VGND VPWR VPWR sky130_fd_sc_hd__decap_3
XFILLER_6_141 VGND VGND VPWR VPWR sky130_fd_sc_hd__decap_3
Xhold609 _6728_/Q VGND VGND VPWR VPWR _6728_/D sky130_fd_sc_hd__dlygate4sd3_1
Xwire573 _6982_/D VGND VGND VPWR VPWR wire573/X sky130_fd_sc_hd__clkbuf_2
X_3370_ _3561_/A _3561_/B VGND VGND VPWR VPWR _3370_/Y sky130_fd_sc_hd__nor2_2
XFILLER_88_70 VGND VGND VPWR VPWR sky130_fd_sc_hd__decap_3
XFILLER_97_402 VGND VGND VPWR VPWR sky130_fd_sc_hd__decap_3
XTAP_TAPCELL_ROW_90_1337 VGND VPWR sky130_fd_sc_hd__tapvpwrvgnd_1
XTAP_TAPCELL_ROW_90_1326 VGND VPWR sky130_fd_sc_hd__tapvpwrvgnd_1
XFILLER_111_234 VGND VGND VPWR VPWR sky130_fd_sc_hd__decap_3
X_5040_ _6989_/D _5039_/X _5156_/S VGND VGND VPWR VPWR _5040_/X sky130_fd_sc_hd__mux2_2
XFILLER_111_256 VGND VGND VPWR VPWR sky130_fd_sc_hd__decap_3
XFILLER_26_3 VGND VGND VPWR VPWR sky130_fd_sc_hd__decap_3
XFILLER_84_118 VGND VGND VPWR VPWR sky130_fd_sc_hd__decap_3
XPHY_EDGE_ROW_108_Left_225 VGND VGND VPWR VPWR sky130_fd_sc_hd__decap_3
XFILLER_65_310 VGND VGND VPWR VPWR sky130_fd_sc_hd__decap_3
XFILLER_77_192 VGND VGND VPWR VPWR sky130_fd_sc_hd__decap_3
XFILLER_65_343 VGND VGND VPWR VPWR sky130_fd_sc_hd__decap_3
X_6991_ _7393_/CLK _6991_/D _6271_/Y VGND VGND VPWR VPWR _6991_/Q sky130_fd_sc_hd__dfrtp_2
XFILLER_65_376 VGND VGND VPWR VPWR sky130_fd_sc_hd__decap_3
XFILLER_92_173 VGND VGND VPWR VPWR sky130_fd_sc_hd__decap_3
XFILLER_18_292 VGND VGND VPWR VPWR sky130_fd_sc_hd__decap_3
XFILLER_80_368 VGND VGND VPWR VPWR sky130_fd_sc_hd__decap_3
XFILLER_80_379 VGND VGND VPWR VPWR sky130_fd_sc_hd__fill_2
XFILLER_33_284 VGND VGND VPWR VPWR sky130_fd_sc_hd__decap_3
XFILLER_33_295 VGND VGND VPWR VPWR sky130_fd_sc_hd__decap_3
XTAP_TAPCELL_ROW_44_780 VGND VPWR sky130_fd_sc_hd__tapvpwrvgnd_1
X_4755_ _7005_/Q _4775_/A VGND VGND VPWR VPWR _7005_/D sky130_fd_sc_hd__xor2_2
X_4686_ _6999_/Q _7000_/Q _4858_/B VGND VGND VPWR VPWR _4687_/B sky130_fd_sc_hd__and3_2
X_6425_ _6584_/A VGND VGND VPWR VPWR _6425_/Y sky130_fd_sc_hd__inv_2
X_3637_ _3636_/Y _5103_/A1 _3505_/X _3618_/X VGND VGND VPWR VPWR _3637_/X sky130_fd_sc_hd__a22o_2
X_6356_ _6388_/A VGND VGND VPWR VPWR _6356_/Y sky130_fd_sc_hd__inv_2
X_3568_ _7093_/Q _3417_/X _3407_/X _7125_/Q VGND VGND VPWR VPWR _3568_/X sky130_fd_sc_hd__a22o_2
XFILLER_68_29 VGND VGND VPWR VPWR sky130_fd_sc_hd__decap_3
XFILLER_88_402 VGND VGND VPWR VPWR sky130_fd_sc_hd__decap_3
XFILLER_88_413 VGND VGND VPWR VPWR sky130_fd_sc_hd__decap_3
XFILLER_102_223 VGND VGND VPWR VPWR sky130_fd_sc_hd__decap_3
XFILLER_88_468 VGND VGND VPWR VPWR sky130_fd_sc_hd__decap_3
X_6287_ _6287_/A VGND VGND VPWR VPWR _6287_/Y sky130_fd_sc_hd__inv_2
X_3499_ _4537_/C _4289_/B _3497_/X _5152_/B VGND VGND VPWR VPWR _3541_/B sky130_fd_sc_hd__a31oi_4
XFILLER_102_256 VGND VGND VPWR VPWR sky130_fd_sc_hd__decap_3
XFILLER_69_671 VGND VGND VPWR VPWR sky130_fd_sc_hd__fill_1
X_5238_ _5362_/C _5238_/B _3378_/Y VGND VGND VPWR VPWR _5238_/X sky130_fd_sc_hd__or3b_2
XTAP_TAPCELL_ROW_110_1573 VGND VPWR sky130_fd_sc_hd__tapvpwrvgnd_1
XFILLER_56_321 VGND VGND VPWR VPWR sky130_fd_sc_hd__decap_3
XFILLER_68_170 VGND VGND VPWR VPWR sky130_fd_sc_hd__decap_3
XFILLER_84_630 VGND VGND VPWR VPWR sky130_fd_sc_hd__decap_3
X_5169_ _5169_/A _5190_/B VGND VGND VPWR VPWR _7243_/D sky130_fd_sc_hd__and2_2
XFILLER_56_354 VGND VGND VPWR VPWR sky130_fd_sc_hd__decap_3
XFILLER_56_365 VGND VGND VPWR VPWR sky130_fd_sc_hd__decap_3
XFILLER_84_663 VGND VGND VPWR VPWR sky130_fd_sc_hd__fill_2
XFILLER_16_218 VGND VGND VPWR VPWR sky130_fd_sc_hd__fill_1
XFILLER_71_302 VGND VGND VPWR VPWR sky130_fd_sc_hd__decap_3
XFILLER_83_162 VGND VGND VPWR VPWR sky130_fd_sc_hd__decap_3
XFILLER_17_88 VGND VGND VPWR VPWR sky130_fd_sc_hd__fill_2
XFILLER_71_346 VGND VGND VPWR VPWR sky130_fd_sc_hd__decap_3
XTAP_TAPCELL_ROW_65_1030 VGND VPWR sky130_fd_sc_hd__tapvpwrvgnd_1
XTAP_TAPCELL_ROW_14_419 VGND VPWR sky130_fd_sc_hd__tapvpwrvgnd_1
XFILLER_12_413 VGND VGND VPWR VPWR sky130_fd_sc_hd__decap_3
XFILLER_12_457 VGND VGND VPWR VPWR sky130_fd_sc_hd__decap_3
XFILLER_33_54 VGND VGND VPWR VPWR sky130_fd_sc_hd__fill_2
XFILLER_3_122 VGND VGND VPWR VPWR sky130_fd_sc_hd__fill_1
XFILLER_4_645 VGND VGND VPWR VPWR sky130_fd_sc_hd__fill_1
XFILLER_3_166 VGND VGND VPWR VPWR sky130_fd_sc_hd__fill_2
XFILLER_79_402 VGND VGND VPWR VPWR sky130_fd_sc_hd__decap_3
XFILLER_106_595 VGND VGND VPWR VPWR sky130_fd_sc_hd__decap_3
XFILLER_79_435 VGND VGND VPWR VPWR sky130_fd_sc_hd__decap_3
XFILLER_79_479 VGND VGND VPWR VPWR sky130_fd_sc_hd__decap_3
XFILLER_94_427 VGND VGND VPWR VPWR sky130_fd_sc_hd__decap_3
XFILLER_12_9 VGND VGND VPWR VPWR sky130_fd_sc_hd__decap_3
XFILLER_35_505 VGND VGND VPWR VPWR sky130_fd_sc_hd__fill_2
XFILLER_47_332 VGND VGND VPWR VPWR sky130_fd_sc_hd__decap_3
XFILLER_47_343 VGND VGND VPWR VPWR sky130_fd_sc_hd__decap_3
XFILLER_75_641 VGND VGND VPWR VPWR sky130_fd_sc_hd__decap_3
XFILLER_74_162 VGND VGND VPWR VPWR sky130_fd_sc_hd__decap_3
XFILLER_62_335 VGND VGND VPWR VPWR sky130_fd_sc_hd__decap_3
XFILLER_74_195 VGND VGND VPWR VPWR sky130_fd_sc_hd__fill_1
XFILLER_74_83 VGND VGND VPWR VPWR sky130_fd_sc_hd__fill_1
XFILLER_15_240 VGND VGND VPWR VPWR sky130_fd_sc_hd__decap_3
XFILLER_15_284 VGND VGND VPWR VPWR sky130_fd_sc_hd__decap_3
XFILLER_95_6 VGND VGND VPWR VPWR sky130_fd_sc_hd__decap_3
XFILLER_30_243 VGND VGND VPWR VPWR sky130_fd_sc_hd__decap_3
XFILLER_90_71 VGND VGND VPWR VPWR sky130_fd_sc_hd__decap_3
XFILLER_30_265 VGND VGND VPWR VPWR sky130_fd_sc_hd__decap_3
XFILLER_30_298 VGND VGND VPWR VPWR sky130_fd_sc_hd__decap_3
XFILLER_116_304 VGND VGND VPWR VPWR sky130_fd_sc_hd__decap_3
Xclkbuf_leaf_10_clk clkbuf_leaf_7_clk/A VGND VGND VPWR VPWR _7393_/CLK sky130_fd_sc_hd__clkbuf_16
X_4540_ _4540_/A _4569_/B VGND VGND VPWR VPWR _7310_/D sky130_fd_sc_hd__and2_2
XFILLER_116_337 VGND VGND VPWR VPWR sky130_fd_sc_hd__decap_3
X_4471_ _7343_/Q _4470_/X _4471_/S VGND VGND VPWR VPWR _7343_/D sky130_fd_sc_hd__mux2_2
XFILLER_116_359 VGND VGND VPWR VPWR sky130_fd_sc_hd__decap_3
X_7190_ clkload1/A _7190_/D _6470_/Y VGND VGND VPWR VPWR _7190_/Q sky130_fd_sc_hd__dfrtp_2
XFILLER_112_510 VGND VGND VPWR VPWR sky130_fd_sc_hd__decap_3
XFILLER_112_543 VGND VGND VPWR VPWR sky130_fd_sc_hd__decap_3
XFILLER_97_243 VGND VGND VPWR VPWR sky130_fd_sc_hd__decap_3
X_3353_ _3353_/A _6979_/Q VGND VGND VPWR VPWR _5668_/A sky130_fd_sc_hd__xor2_2
XFILLER_112_587 VGND VGND VPWR VPWR sky130_fd_sc_hd__fill_1
XFILLER_57_107 VGND VGND VPWR VPWR sky130_fd_sc_hd__decap_3
XFILLER_85_405 VGND VGND VPWR VPWR sky130_fd_sc_hd__decap_3
Xhold1106 _7037_/Q VGND VGND VPWR VPWR _5583_/A0 sky130_fd_sc_hd__dlygate4sd3_1
XFILLER_85_438 VGND VGND VPWR VPWR sky130_fd_sc_hd__decap_3
XFILLER_85_449 VGND VGND VPWR VPWR sky130_fd_sc_hd__decap_3
XFILLER_97_287 VGND VGND VPWR VPWR sky130_fd_sc_hd__decap_3
Xhold1117 _7042_/Q VGND VGND VPWR VPWR _5575_/A1 sky130_fd_sc_hd__dlygate4sd3_1
Xhold1128 _7337_/Q VGND VGND VPWR VPWR _4484_/A0 sky130_fd_sc_hd__dlygate4sd3_1
Xhold1139 _7269_/Q VGND VGND VPWR VPWR _4879_/A0 sky130_fd_sc_hd__dlygate4sd3_1
X_5023_ _5661_/A VGND VGND VPWR VPWR _5023_/Y sky130_fd_sc_hd__inv_2
XFILLER_66_641 VGND VGND VPWR VPWR sky130_fd_sc_hd__decap_3
XFILLER_38_365 VGND VGND VPWR VPWR sky130_fd_sc_hd__fill_1
XFILLER_38_387 VGND VGND VPWR VPWR sky130_fd_sc_hd__decap_3
XFILLER_53_302 VGND VGND VPWR VPWR sky130_fd_sc_hd__decap_3
XFILLER_65_162 VGND VGND VPWR VPWR sky130_fd_sc_hd__decap_3
XFILLER_81_600 VGND VGND VPWR VPWR sky130_fd_sc_hd__decap_3
XFILLER_53_335 VGND VGND VPWR VPWR sky130_fd_sc_hd__fill_1
XFILLER_53_346 VGND VGND VPWR VPWR sky130_fd_sc_hd__decap_3
XFILLER_65_184 VGND VGND VPWR VPWR sky130_fd_sc_hd__decap_3
XFILLER_80_110 VGND VGND VPWR VPWR sky130_fd_sc_hd__fill_1
XFILLER_81_666 VGND VGND VPWR VPWR sky130_fd_sc_hd__decap_3
XFILLER_93_493 VGND VGND VPWR VPWR sky130_fd_sc_hd__decap_3
X_6974_ _6976_/CLK _6974_/D VGND VGND VPWR VPWR _6974_/Q sky130_fd_sc_hd__dfxtp_2
XFILLER_110_26 VGND VGND VPWR VPWR sky130_fd_sc_hd__fill_2
XFILLER_41_508 VGND VGND VPWR VPWR sky130_fd_sc_hd__decap_3
XFILLER_53_379 VGND VGND VPWR VPWR sky130_fd_sc_hd__decap_3
XFILLER_80_154 VGND VGND VPWR VPWR sky130_fd_sc_hd__decap_3
XFILLER_81_688 VGND VGND VPWR VPWR sky130_fd_sc_hd__decap_3
XFILLER_80_187 VGND VGND VPWR VPWR sky130_fd_sc_hd__decap_3
XFILLER_21_243 VGND VGND VPWR VPWR sky130_fd_sc_hd__decap_3
X_4807_ _4807_/A0 _4806_/X _4879_/S VGND VGND VPWR VPWR _7273_/D sky130_fd_sc_hd__mux2_2
XPHY_EDGE_ROW_3_Right_3 VGND VGND VPWR VPWR sky130_fd_sc_hd__decap_3
XFILLER_21_287 VGND VGND VPWR VPWR sky130_fd_sc_hd__decap_3
XFILLER_107_304 VGND VGND VPWR VPWR sky130_fd_sc_hd__decap_3
X_4738_ _4738_/A _4738_/B VGND VGND VPWR VPWR _7006_/D sky130_fd_sc_hd__nor2_2
XFILLER_107_337 VGND VGND VPWR VPWR sky130_fd_sc_hd__decap_3
XFILLER_79_17 VGND VGND VPWR VPWR sky130_fd_sc_hd__fill_1
X_4669_ _6995_/Q _5605_/B VGND VGND VPWR VPWR _4928_/B sky130_fd_sc_hd__and2_2
XFILLER_79_28 VGND VGND VPWR VPWR sky130_fd_sc_hd__decap_3
XFILLER_79_39 VGND VGND VPWR VPWR sky130_fd_sc_hd__decap_3
Xhold940 _7033_/Q VGND VGND VPWR VPWR _5589_/A sky130_fd_sc_hd__dlygate4sd3_1
X_6408_ _6570_/A VGND VGND VPWR VPWR _6408_/Y sky130_fd_sc_hd__inv_2
X_7388_ _7394_/CLK _7388_/D _6668_/Y VGND VGND VPWR VPWR _7388_/Q sky130_fd_sc_hd__dfrtp_2
Xhold973 _7032_/Q VGND VGND VPWR VPWR _5591_/A sky130_fd_sc_hd__dlygate4sd3_1
Xhold962 _7027_/Q VGND VGND VPWR VPWR _5600_/A sky130_fd_sc_hd__dlygate4sd3_1
Xhold951 _6690_/Q VGND VGND VPWR VPWR hold951/X sky130_fd_sc_hd__dlygate4sd3_1
XFILLER_115_381 VGND VGND VPWR VPWR sky130_fd_sc_hd__decap_3
XFILLER_1_659 VGND VGND VPWR VPWR sky130_fd_sc_hd__decap_3
Xhold995 _7271_/Q VGND VGND VPWR VPWR hold995/X sky130_fd_sc_hd__dlygate4sd3_1
Xhold984 _7044_/Q VGND VGND VPWR VPWR hold984/X sky130_fd_sc_hd__dlygate4sd3_1
X_6339_ _6347_/A VGND VGND VPWR VPWR _6339_/Y sky130_fd_sc_hd__inv_2
XFILLER_0_147 VGND VGND VPWR VPWR sky130_fd_sc_hd__decap_3
XFILLER_0_158 VGND VGND VPWR VPWR sky130_fd_sc_hd__decap_3
XFILLER_103_576 VGND VGND VPWR VPWR sky130_fd_sc_hd__decap_3
XFILLER_88_265 VGND VGND VPWR VPWR sky130_fd_sc_hd__decap_3
XFILLER_95_27 VGND VGND VPWR VPWR sky130_fd_sc_hd__decap_3
XFILLER_28_21 VGND VGND VPWR VPWR sky130_fd_sc_hd__decap_3
XFILLER_28_32 VGND VGND VPWR VPWR sky130_fd_sc_hd__decap_3
XFILLER_29_310 VGND VGND VPWR VPWR sky130_fd_sc_hd__decap_3
XFILLER_76_427 VGND VGND VPWR VPWR sky130_fd_sc_hd__decap_3
XFILLER_95_49 VGND VGND VPWR VPWR sky130_fd_sc_hd__fill_1
XFILLER_29_332 VGND VGND VPWR VPWR sky130_fd_sc_hd__decap_3
XFILLER_91_408 VGND VGND VPWR VPWR sky130_fd_sc_hd__decap_3
XFILLER_56_162 VGND VGND VPWR VPWR sky130_fd_sc_hd__decap_3
XFILLER_72_622 VGND VGND VPWR VPWR sky130_fd_sc_hd__decap_3
XFILLER_84_471 VGND VGND VPWR VPWR sky130_fd_sc_hd__decap_3
XFILLER_44_324 VGND VGND VPWR VPWR sky130_fd_sc_hd__decap_3
XFILLER_56_195 VGND VGND VPWR VPWR sky130_fd_sc_hd__fill_1
XFILLER_72_655 VGND VGND VPWR VPWR sky130_fd_sc_hd__decap_3
XFILLER_44_368 VGND VGND VPWR VPWR sky130_fd_sc_hd__decap_3
XFILLER_71_143 VGND VGND VPWR VPWR sky130_fd_sc_hd__decap_3
XTAP_TAPCELL_ROW_27_577 VGND VPWR sky130_fd_sc_hd__tapvpwrvgnd_1
XFILLER_12_221 VGND VGND VPWR VPWR sky130_fd_sc_hd__fill_2
XFILLER_71_187 VGND VGND VPWR VPWR sky130_fd_sc_hd__decap_3
XFILLER_12_243 VGND VGND VPWR VPWR sky130_fd_sc_hd__decap_3
XFILLER_8_203 VGND VGND VPWR VPWR sky130_fd_sc_hd__decap_3
XFILLER_100_70 VGND VGND VPWR VPWR sky130_fd_sc_hd__decap_3
XFILLER_12_265 VGND VGND VPWR VPWR sky130_fd_sc_hd__decap_3
XFILLER_12_298 VGND VGND VPWR VPWR sky130_fd_sc_hd__decap_3
XFILLER_60_41 VGND VGND VPWR VPWR sky130_fd_sc_hd__fill_1
XFILLER_60_52 VGND VGND VPWR VPWR sky130_fd_sc_hd__decap_3
XFILLER_8_247 VGND VGND VPWR VPWR sky130_fd_sc_hd__decap_3
XFILLER_60_85 VGND VGND VPWR VPWR sky130_fd_sc_hd__fill_1
XFILLER_5_36 VGND VGND VPWR VPWR sky130_fd_sc_hd__decap_3
XFILLER_99_508 VGND VGND VPWR VPWR sky130_fd_sc_hd__decap_3
XFILLER_113_329 VGND VGND VPWR VPWR sky130_fd_sc_hd__decap_3
XFILLER_4_497 VGND VGND VPWR VPWR sky130_fd_sc_hd__decap_3
XFILLER_79_210 VGND VGND VPWR VPWR sky130_fd_sc_hd__decap_3
XFILLER_79_254 VGND VGND VPWR VPWR sky130_fd_sc_hd__decap_3
XFILLER_0_681 VGND VGND VPWR VPWR sky130_fd_sc_hd__fill_1
XFILLER_67_449 VGND VGND VPWR VPWR sky130_fd_sc_hd__fill_1
XFILLER_94_224 VGND VGND VPWR VPWR sky130_fd_sc_hd__decap_3
XFILLER_10_6 VGND VGND VPWR VPWR sky130_fd_sc_hd__fill_2
XFILLER_85_60 VGND VGND VPWR VPWR sky130_fd_sc_hd__decap_3
XFILLER_94_268 VGND VGND VPWR VPWR sky130_fd_sc_hd__fill_1
XFILLER_35_313 VGND VGND VPWR VPWR sky130_fd_sc_hd__fill_2
XFILLER_85_93 VGND VGND VPWR VPWR sky130_fd_sc_hd__decap_3
XFILLER_35_346 VGND VGND VPWR VPWR sky130_fd_sc_hd__decap_3
XFILLER_47_184 VGND VGND VPWR VPWR sky130_fd_sc_hd__decap_3
XFILLER_35_357 VGND VGND VPWR VPWR sky130_fd_sc_hd__decap_3
XFILLER_62_154 VGND VGND VPWR VPWR sky130_fd_sc_hd__decap_3
XTAP_TAPCELL_ROW_85_1269 VGND VPWR sky130_fd_sc_hd__tapvpwrvgnd_1
XFILLER_50_327 VGND VGND VPWR VPWR sky130_fd_sc_hd__decap_3
X_5710_ _7361_/Q hold927/X _5729_/S VGND VGND VPWR VPWR _6705_/D sky130_fd_sc_hd__mux2_2
XFILLER_93_3 VGND VGND VPWR VPWR sky130_fd_sc_hd__decap_3
X_6690_ _7384_/CLK _6690_/D VGND VGND VPWR VPWR _6690_/Q sky130_fd_sc_hd__dfxtp_2
X_5641_ _5641_/A VGND VGND VPWR VPWR _5641_/Y sky130_fd_sc_hd__inv_2
X_5572_ _5572_/A1 _4960_/A _4961_/C VGND VGND VPWR VPWR _7045_/D sky130_fd_sc_hd__a21o_2
X_7311_ _7381_/CLK _7311_/D _6591_/Y VGND VGND VPWR VPWR _7311_/Q sky130_fd_sc_hd__dfrtp_2
X_7242_ _7365_/CLK _7242_/D _6522_/Y VGND VGND VPWR VPWR _7242_/Q sky130_fd_sc_hd__dfrtp_2
XFILLER_104_318 VGND VGND VPWR VPWR sky130_fd_sc_hd__decap_3
XFILLER_116_178 VGND VGND VPWR VPWR sky130_fd_sc_hd__decap_3
X_4454_ _4761_/B _4761_/C _4745_/A _4762_/B VGND VGND VPWR VPWR _4454_/X sky130_fd_sc_hd__a211o_2
XTAP_TAPCELL_ROW_96_1398 VGND VPWR sky130_fd_sc_hd__tapvpwrvgnd_1
X_7173_ _7365_/CLK _7173_/D _6453_/Y VGND VGND VPWR VPWR _7173_/Q sky130_fd_sc_hd__dfrtp_2
X_4385_ _7337_/Q _3945_/S _5229_/C _7145_/Q VGND VGND VPWR VPWR _4385_/X sky130_fd_sc_hd__a22o_2
X_3405_ _6982_/Q _4697_/A _3340_/C _5634_/B VGND VGND VPWR VPWR _3409_/D sky130_fd_sc_hd__o31a_2
XFILLER_112_362 VGND VGND VPWR VPWR sky130_fd_sc_hd__fill_2
XFILLER_98_563 VGND VGND VPWR VPWR sky130_fd_sc_hd__decap_3
XFILLER_112_395 VGND VGND VPWR VPWR sky130_fd_sc_hd__decap_3
XFILLER_58_427 VGND VGND VPWR VPWR sky130_fd_sc_hd__decap_3
X_5006_ _3604_/B _4626_/X _5003_/A _5033_/B2 VGND VGND VPWR VPWR _5006_/X sky130_fd_sc_hd__a22o_2
XFILLER_38_162 VGND VGND VPWR VPWR sky130_fd_sc_hd__decap_3
XFILLER_73_419 VGND VGND VPWR VPWR sky130_fd_sc_hd__decap_3
XFILLER_26_324 VGND VGND VPWR VPWR sky130_fd_sc_hd__decap_3
XFILLER_26_335 VGND VGND VPWR VPWR sky130_fd_sc_hd__decap_3
XFILLER_38_195 VGND VGND VPWR VPWR sky130_fd_sc_hd__fill_1
XFILLER_26_368 VGND VGND VPWR VPWR sky130_fd_sc_hd__decap_3
XFILLER_41_305 VGND VGND VPWR VPWR sky130_fd_sc_hd__decap_3
XFILLER_81_452 VGND VGND VPWR VPWR sky130_fd_sc_hd__decap_3
X_6957_ _6978_/CLK _6957_/D VGND VGND VPWR VPWR _6957_/Q sky130_fd_sc_hd__dfxtp_2
XFILLER_41_316 VGND VGND VPWR VPWR sky130_fd_sc_hd__fill_1
XFILLER_81_485 VGND VGND VPWR VPWR sky130_fd_sc_hd__decap_3
XTAP_TAPCELL_ROW_62_1000 VGND VPWR sky130_fd_sc_hd__tapvpwrvgnd_1
XTAP_TAPCELL_ROW_24_536 VGND VPWR sky130_fd_sc_hd__tapvpwrvgnd_1
X_6888_ _6965_/CLK _6888_/D VGND VGND VPWR VPWR _6888_/Q sky130_fd_sc_hd__dfxtp_2
XTAP_TAPCELL_ROW_52_878 VGND VPWR sky130_fd_sc_hd__tapvpwrvgnd_1
XFILLER_22_585 VGND VGND VPWR VPWR sky130_fd_sc_hd__decap_3
XFILLER_5_217 VGND VGND VPWR VPWR sky130_fd_sc_hd__decap_3
XFILLER_30_55 VGND VGND VPWR VPWR sky130_fd_sc_hd__decap_3
XFILLER_5_239 VGND VGND VPWR VPWR sky130_fd_sc_hd__decap_3
XFILLER_107_156 VGND VGND VPWR VPWR sky130_fd_sc_hd__decap_3
XFILLER_30_88 VGND VGND VPWR VPWR sky130_fd_sc_hd__decap_3
Xhold770 _6730_/Q VGND VGND VPWR VPWR _6730_/D sky130_fd_sc_hd__dlygate4sd3_1
Xhold781 _6843_/Q VGND VGND VPWR VPWR _6843_/D sky130_fd_sc_hd__dlygate4sd3_1
XFILLER_103_340 VGND VGND VPWR VPWR sky130_fd_sc_hd__decap_3
Xhold792 _6939_/Q VGND VGND VPWR VPWR _6939_/D sky130_fd_sc_hd__dlygate4sd3_1
XFILLER_103_373 VGND VGND VPWR VPWR sky130_fd_sc_hd__decap_3
XFILLER_49_416 VGND VGND VPWR VPWR sky130_fd_sc_hd__decap_3
XFILLER_49_449 VGND VGND VPWR VPWR sky130_fd_sc_hd__decap_3
XFILLER_76_235 VGND VGND VPWR VPWR sky130_fd_sc_hd__decap_3
XFILLER_29_140 VGND VGND VPWR VPWR sky130_fd_sc_hd__decap_3
XFILLER_76_279 VGND VGND VPWR VPWR sky130_fd_sc_hd__decap_3
XTAP_TAPCELL_ROW_4_294 VGND VPWR sky130_fd_sc_hd__tapvpwrvgnd_1
XFILLER_17_335 VGND VGND VPWR VPWR sky130_fd_sc_hd__fill_1
XFILLER_29_184 VGND VGND VPWR VPWR sky130_fd_sc_hd__decap_3
XFILLER_44_110 VGND VGND VPWR VPWR sky130_fd_sc_hd__decap_3
XFILLER_72_430 VGND VGND VPWR VPWR sky130_fd_sc_hd__decap_3
XFILLER_44_154 VGND VGND VPWR VPWR sky130_fd_sc_hd__decap_3
XFILLER_45_666 VGND VGND VPWR VPWR sky130_fd_sc_hd__decap_3
XFILLER_55_63 VGND VGND VPWR VPWR sky130_fd_sc_hd__decap_3
XFILLER_72_463 VGND VGND VPWR VPWR sky130_fd_sc_hd__decap_3
XFILLER_44_187 VGND VGND VPWR VPWR sky130_fd_sc_hd__decap_3
XFILLER_13_530 VGND VGND VPWR VPWR sky130_fd_sc_hd__fill_1
XFILLER_40_360 VGND VGND VPWR VPWR sky130_fd_sc_hd__decap_3
XFILLER_40_371 VGND VGND VPWR VPWR sky130_fd_sc_hd__decap_3
XFILLER_9_523 VGND VGND VPWR VPWR sky130_fd_sc_hd__fill_1
XFILLER_40_393 VGND VGND VPWR VPWR sky130_fd_sc_hd__decap_3
XFILLER_4_250 VGND VGND VPWR VPWR sky130_fd_sc_hd__fill_2
XFILLER_58_6 VGND VGND VPWR VPWR sky130_fd_sc_hd__decap_3
XFILLER_4_261 VGND VGND VPWR VPWR sky130_fd_sc_hd__decap_3
XFILLER_4_294 VGND VGND VPWR VPWR sky130_fd_sc_hd__decap_3
XFILLER_113_148 VGND VGND VPWR VPWR sky130_fd_sc_hd__decap_3
XFILLER_95_500 VGND VGND VPWR VPWR sky130_fd_sc_hd__decap_3
X_4170_ _4203_/A _4203_/B _4202_/A VGND VGND VPWR VPWR _4938_/B sky130_fd_sc_hd__and3_2
XFILLER_67_213 VGND VGND VPWR VPWR sky130_fd_sc_hd__decap_3
XFILLER_95_511 VGND VGND VPWR VPWR sky130_fd_sc_hd__decap_3
XFILLER_67_246 VGND VGND VPWR VPWR sky130_fd_sc_hd__decap_3
XFILLER_95_544 VGND VGND VPWR VPWR sky130_fd_sc_hd__decap_3
XFILLER_48_460 VGND VGND VPWR VPWR sky130_fd_sc_hd__decap_3
XFILLER_35_110 VGND VGND VPWR VPWR sky130_fd_sc_hd__fill_2
XFILLER_35_143 VGND VGND VPWR VPWR sky130_fd_sc_hd__decap_3
XFILLER_35_165 VGND VGND VPWR VPWR sky130_fd_sc_hd__decap_3
XFILLER_63_441 VGND VGND VPWR VPWR sky130_fd_sc_hd__decap_3
XFILLER_63_452 VGND VGND VPWR VPWR sky130_fd_sc_hd__decap_3
XFILLER_63_463 VGND VGND VPWR VPWR sky130_fd_sc_hd__decap_3
Xplace430 _3996_/S VGND VGND VPWR VPWR _3977_/S sky130_fd_sc_hd__buf_2
X_6811_ _6976_/CLK _6811_/D VGND VGND VPWR VPWR _6811_/Q sky130_fd_sc_hd__dfxtp_2
XFILLER_35_176 VGND VGND VPWR VPWR sky130_fd_sc_hd__decap_3
XFILLER_35_198 VGND VGND VPWR VPWR sky130_fd_sc_hd__decap_3
XFILLER_50_124 VGND VGND VPWR VPWR sky130_fd_sc_hd__fill_1
XFILLER_63_485 VGND VGND VPWR VPWR sky130_fd_sc_hd__fill_2
Xplace441 _3341_/A VGND VGND VPWR VPWR _5156_/S sky130_fd_sc_hd__buf_2
Xplace452 _3318_/B VGND VGND VPWR VPWR _4469_/A3 sky130_fd_sc_hd__buf_2
Xplace463 _5129_/B VGND VGND VPWR VPWR _3362_/A sky130_fd_sc_hd__buf_2
X_6742_ _6972_/CLK _6742_/D VGND VGND VPWR VPWR _6742_/Q sky130_fd_sc_hd__dfxtp_2
X_3954_ _7363_/Q _4497_/A0 _3958_/S VGND VGND VPWR VPWR _7363_/D sky130_fd_sc_hd__mux2_2
XFILLER_50_168 VGND VGND VPWR VPWR sky130_fd_sc_hd__decap_3
X_6673_ _6674_/A VGND VGND VPWR VPWR _6673_/Y sky130_fd_sc_hd__inv_2
X_3885_ _3746_/X _3882_/X _3884_/X _3725_/X VGND VGND VPWR VPWR _3885_/X sky130_fd_sc_hd__a22o_2
XTAP_TAPCELL_ROW_21_506 VGND VPWR sky130_fd_sc_hd__tapvpwrvgnd_1
XFILLER_31_382 VGND VGND VPWR VPWR sky130_fd_sc_hd__decap_3
X_5624_ _5624_/A _5633_/B VGND VGND VPWR VPWR _7016_/D sky130_fd_sc_hd__or2_2
XTAP_TAPCELL_ROW_98_1427 VGND VPWR sky130_fd_sc_hd__tapvpwrvgnd_1
XFILLER_104_104 VGND VGND VPWR VPWR sky130_fd_sc_hd__fill_2
XFILLER_105_638 VGND VGND VPWR VPWR sky130_fd_sc_hd__decap_3
X_7225_ _7394_/CLK _7225_/D _6505_/Y VGND VGND VPWR VPWR _7225_/Q sky130_fd_sc_hd__dfrtp_2
X_4437_ _7022_/Q _4437_/A2 _4437_/B1 _7399_/Q _4436_/X VGND VGND VPWR VPWR _4437_/X
+ sky130_fd_sc_hd__a221o_2
X_7156_ clkload5/A _7156_/D _6436_/Y VGND VGND VPWR VPWR _7156_/Q sky130_fd_sc_hd__dfrtp_2
XFILLER_58_224 VGND VGND VPWR VPWR sky130_fd_sc_hd__decap_3
XFILLER_76_29 VGND VGND VPWR VPWR sky130_fd_sc_hd__decap_3
XFILLER_86_533 VGND VGND VPWR VPWR sky130_fd_sc_hd__decap_3
X_4368_ _5073_/A _4366_/X _5054_/A VGND VGND VPWR VPWR _4369_/B sky130_fd_sc_hd__a21oi_2
XFILLER_112_192 VGND VGND VPWR VPWR sky130_fd_sc_hd__decap_3
X_7087_ clkload5/A _7087_/D _6367_/Y VGND VGND VPWR VPWR _7087_/Q sky130_fd_sc_hd__dfstp_2
X_4299_ _3620_/A _4292_/X _4298_/X VGND VGND VPWR VPWR _5100_/B sky130_fd_sc_hd__a21o_2
X_3319_ _3378_/A _5646_/A _5647_/A _5647_/B VGND VGND VPWR VPWR _3319_/X sky130_fd_sc_hd__and4b_4
XFILLER_100_354 VGND VGND VPWR VPWR sky130_fd_sc_hd__decap_3
XFILLER_100_365 VGND VGND VPWR VPWR sky130_fd_sc_hd__decap_3
XFILLER_58_279 VGND VGND VPWR VPWR sky130_fd_sc_hd__decap_3
XTAP_TAPCELL_ROW_57_937 VGND VPWR sky130_fd_sc_hd__tapvpwrvgnd_1
XFILLER_100_398 VGND VGND VPWR VPWR sky130_fd_sc_hd__decap_3
XFILLER_26_121 VGND VGND VPWR VPWR sky130_fd_sc_hd__decap_3
XFILLER_54_430 VGND VGND VPWR VPWR sky130_fd_sc_hd__decap_3
XFILLER_92_17 VGND VGND VPWR VPWR sky130_fd_sc_hd__decap_3
XTAP_TAPCELL_ROW_107_1534 VGND VPWR sky130_fd_sc_hd__tapvpwrvgnd_1
XTAP_TAPCELL_ROW_1_264 VGND VPWR sky130_fd_sc_hd__tapvpwrvgnd_1
XFILLER_14_305 VGND VGND VPWR VPWR sky130_fd_sc_hd__decap_3
XFILLER_25_33 VGND VGND VPWR VPWR sky130_fd_sc_hd__decap_3
XFILLER_26_176 VGND VGND VPWR VPWR sky130_fd_sc_hd__decap_3
XFILLER_41_113 VGND VGND VPWR VPWR sky130_fd_sc_hd__decap_3
XFILLER_54_474 VGND VGND VPWR VPWR sky130_fd_sc_hd__fill_2
XFILLER_81_260 VGND VGND VPWR VPWR sky130_fd_sc_hd__decap_3
XTAP_TAPCELL_ROW_37_694 VGND VPWR sky130_fd_sc_hd__tapvpwrvgnd_1
XFILLER_25_66 VGND VGND VPWR VPWR sky130_fd_sc_hd__fill_2
XFILLER_81_293 VGND VGND VPWR VPWR sky130_fd_sc_hd__decap_3
XFILLER_22_360 VGND VGND VPWR VPWR sky130_fd_sc_hd__decap_3
XFILLER_22_371 VGND VGND VPWR VPWR sky130_fd_sc_hd__decap_3
XFILLER_25_99 VGND VGND VPWR VPWR sky130_fd_sc_hd__decap_3
XFILLER_10_544 VGND VGND VPWR VPWR sky130_fd_sc_hd__decap_3
XFILLER_108_421 VGND VGND VPWR VPWR sky130_fd_sc_hd__decap_3
XFILLER_41_87 VGND VGND VPWR VPWR sky130_fd_sc_hd__decap_3
XFILLER_41_98 VGND VGND VPWR VPWR sky130_fd_sc_hd__decap_3
XFILLER_108_465 VGND VGND VPWR VPWR sky130_fd_sc_hd__decap_3
XFILLER_1_220 VGND VGND VPWR VPWR sky130_fd_sc_hd__fill_1
XTAP_TAPCELL_ROW_9_364 VGND VPWR sky130_fd_sc_hd__tapvpwrvgnd_1
XFILLER_110_107 VGND VGND VPWR VPWR sky130_fd_sc_hd__decap_3
XFILLER_110_118 VGND VGND VPWR VPWR sky130_fd_sc_hd__decap_3
XFILLER_77_511 VGND VGND VPWR VPWR sky130_fd_sc_hd__decap_3
XFILLER_89_371 VGND VGND VPWR VPWR sky130_fd_sc_hd__fill_1
XFILLER_103_181 VGND VGND VPWR VPWR sky130_fd_sc_hd__decap_3
XFILLER_106_80 VGND VGND VPWR VPWR sky130_fd_sc_hd__decap_3
XFILLER_77_544 VGND VGND VPWR VPWR sky130_fd_sc_hd__decap_3
XFILLER_89_393 VGND VGND VPWR VPWR sky130_fd_sc_hd__decap_3
XFILLER_66_62 VGND VGND VPWR VPWR sky130_fd_sc_hd__decap_3
XFILLER_77_577 VGND VGND VPWR VPWR sky130_fd_sc_hd__decap_3
XFILLER_57_290 VGND VGND VPWR VPWR sky130_fd_sc_hd__decap_3
XFILLER_64_249 VGND VGND VPWR VPWR sky130_fd_sc_hd__decap_3
XFILLER_66_95 VGND VGND VPWR VPWR sky130_fd_sc_hd__decap_3
XFILLER_92_536 VGND VGND VPWR VPWR sky130_fd_sc_hd__decap_3
XFILLER_45_452 VGND VGND VPWR VPWR sky130_fd_sc_hd__decap_3
XFILLER_17_165 VGND VGND VPWR VPWR sky130_fd_sc_hd__decap_3
XFILLER_33_625 VGND VGND VPWR VPWR sky130_fd_sc_hd__fill_1
XFILLER_45_485 VGND VGND VPWR VPWR sky130_fd_sc_hd__decap_3
XFILLER_60_400 VGND VGND VPWR VPWR sky130_fd_sc_hd__decap_3
XFILLER_72_271 VGND VGND VPWR VPWR sky130_fd_sc_hd__decap_3
XFILLER_32_124 VGND VGND VPWR VPWR sky130_fd_sc_hd__decap_3
XFILLER_60_433 VGND VGND VPWR VPWR sky130_fd_sc_hd__decap_3
XTAP_TAPCELL_ROW_82_1239 VGND VPWR sky130_fd_sc_hd__tapvpwrvgnd_1
XFILLER_60_466 VGND VGND VPWR VPWR sky130_fd_sc_hd__decap_3
XFILLER_13_393 VGND VGND VPWR VPWR sky130_fd_sc_hd__decap_3
X_3670_ _3629_/A _3669_/X _3753_/B1 VGND VGND VPWR VPWR _3670_/X sky130_fd_sc_hd__a21o_2
XFILLER_56_3 VGND VGND VPWR VPWR sky130_fd_sc_hd__decap_3
X_5340_ _5340_/A0 _5079_/X _5340_/S VGND VGND VPWR VPWR _7161_/D sky130_fd_sc_hd__mux2_2
XFILLER_99_102 VGND VGND VPWR VPWR sky130_fd_sc_hd__decap_3
XFILLER_114_424 VGND VGND VPWR VPWR sky130_fd_sc_hd__decap_3
XTAP_TAPCELL_ROW_93_1368 VGND VPWR sky130_fd_sc_hd__tapvpwrvgnd_1
XFILLER_99_113 VGND VGND VPWR VPWR sky130_fd_sc_hd__decap_3
XFILLER_114_446 VGND VGND VPWR VPWR sky130_fd_sc_hd__decap_3
XFILLER_87_308 VGND VGND VPWR VPWR sky130_fd_sc_hd__decap_3
X_7010_ _7330_/CLK _7010_/D _6290_/Y VGND VGND VPWR VPWR _7010_/Q sky130_fd_sc_hd__dfrtp_2
X_4222_ _7356_/Q _4270_/B _4221_/X VGND VGND VPWR VPWR _4222_/X sky130_fd_sc_hd__a21o_2
XFILLER_68_500 VGND VGND VPWR VPWR sky130_fd_sc_hd__decap_3
XFILLER_110_641 VGND VGND VPWR VPWR sky130_fd_sc_hd__decap_3
XFILLER_68_533 VGND VGND VPWR VPWR sky130_fd_sc_hd__decap_3
XFILLER_68_566 VGND VGND VPWR VPWR sky130_fd_sc_hd__decap_3
X_4153_ _7298_/Q _4946_/S _4267_/B1 _7170_/Q _4152_/X VGND VGND VPWR VPWR _4153_/X
+ sky130_fd_sc_hd__a221o_2
XFILLER_55_216 VGND VGND VPWR VPWR sky130_fd_sc_hd__decap_3
XFILLER_83_503 VGND VGND VPWR VPWR sky130_fd_sc_hd__fill_1
XFILLER_83_514 VGND VGND VPWR VPWR sky130_fd_sc_hd__decap_3
XFILLER_95_352 VGND VGND VPWR VPWR sky130_fd_sc_hd__fill_2
X_4084_ _7302_/Q _4486_/S _4083_/X _4429_/C1 VGND VGND VPWR VPWR _4084_/X sky130_fd_sc_hd__a211o_2
XFILLER_55_249 VGND VGND VPWR VPWR sky130_fd_sc_hd__decap_3
XFILLER_83_558 VGND VGND VPWR VPWR sky130_fd_sc_hd__fill_2
XFILLER_36_452 VGND VGND VPWR VPWR sky130_fd_sc_hd__decap_3
XFILLER_23_113 VGND VGND VPWR VPWR sky130_fd_sc_hd__decap_3
XFILLER_51_411 VGND VGND VPWR VPWR sky130_fd_sc_hd__decap_3
XFILLER_51_455 VGND VGND VPWR VPWR sky130_fd_sc_hd__decap_3
XFILLER_63_293 VGND VGND VPWR VPWR sky130_fd_sc_hd__decap_3
Xplace282 _3892_/A2 VGND VGND VPWR VPWR _3869_/A2 sky130_fd_sc_hd__buf_2
Xplace271 _3892_/B1 VGND VGND VPWR VPWR _3827_/B1 sky130_fd_sc_hd__buf_2
X_4986_ _5003_/A _5003_/B _4626_/X VGND VGND VPWR VPWR _4987_/B sky130_fd_sc_hd__a21oi_2
XFILLER_11_308 VGND VGND VPWR VPWR sky130_fd_sc_hd__fill_2
Xplace293 _3656_/Y VGND VGND VPWR VPWR _3890_/B1 sky130_fd_sc_hd__buf_2
X_6725_ clkload1/A _6725_/D VGND VGND VPWR VPWR _6725_/Q sky130_fd_sc_hd__dfxtp_2
X_3937_ _7371_/Q _4480_/A0 _3945_/S VGND VGND VPWR VPWR _7371_/D sky130_fd_sc_hd__mux2_2
XTAP_TAPCELL_ROW_62_995 VGND VPWR sky130_fd_sc_hd__tapvpwrvgnd_1
XTAP_TAPCELL_ROW_34_664 VGND VPWR sky130_fd_sc_hd__tapvpwrvgnd_1
XTAP_TAPCELL_ROW_102_1475 VGND VPWR sky130_fd_sc_hd__tapvpwrvgnd_1
XFILLER_109_218 VGND VGND VPWR VPWR sky130_fd_sc_hd__decap_3
X_6656_ _6670_/A VGND VGND VPWR VPWR _6656_/Y sky130_fd_sc_hd__inv_2
X_3868_ hold982/X _5104_/A _3867_/X VGND VGND VPWR VPWR _7384_/D sky130_fd_sc_hd__a21o_2
X_6587_ _6587_/A VGND VGND VPWR VPWR _6587_/Y sky130_fd_sc_hd__inv_2
X_5607_ _5607_/A _5611_/B VGND VGND VPWR VPWR _7024_/D sky130_fd_sc_hd__and2_2
X_3799_ _6909_/Q _3890_/A2 _3889_/B1 _6853_/Q VGND VGND VPWR VPWR _3799_/X sky130_fd_sc_hd__a22o_2
XFILLER_105_402 VGND VGND VPWR VPWR sky130_fd_sc_hd__fill_2
XFILLER_11_46 VGND VGND VPWR VPWR sky130_fd_sc_hd__decap_3
XFILLER_11_57 VGND VGND VPWR VPWR sky130_fd_sc_hd__decap_3
XFILLER_105_413 VGND VGND VPWR VPWR sky130_fd_sc_hd__fill_1
XFILLER_105_435 VGND VGND VPWR VPWR sky130_fd_sc_hd__fill_2
XFILLER_105_479 VGND VGND VPWR VPWR sky130_fd_sc_hd__decap_3
XFILLER_87_39 VGND VGND VPWR VPWR sky130_fd_sc_hd__decap_3
X_7208_ _7393_/CLK _7208_/D _6488_/Y VGND VGND VPWR VPWR _7208_/Q sky130_fd_sc_hd__dfrtp_2
XFILLER_59_511 VGND VGND VPWR VPWR sky130_fd_sc_hd__decap_3
XTAP_TAPCELL_ROW_6_323 VGND VPWR sky130_fd_sc_hd__tapvpwrvgnd_1
XFILLER_101_641 VGND VGND VPWR VPWR sky130_fd_sc_hd__decap_3
XFILLER_59_533 VGND VGND VPWR VPWR sky130_fd_sc_hd__decap_3
XFILLER_86_330 VGND VGND VPWR VPWR sky130_fd_sc_hd__decap_3
X_7139_ _7363_/CLK _7139_/D _6419_/Y VGND VGND VPWR VPWR _7139_/Q sky130_fd_sc_hd__dfrtp_2
XFILLER_19_408 VGND VGND VPWR VPWR sky130_fd_sc_hd__decap_3
XFILLER_74_514 VGND VGND VPWR VPWR sky130_fd_sc_hd__decap_3
XFILLER_86_363 VGND VGND VPWR VPWR sky130_fd_sc_hd__fill_1
XFILLER_86_374 VGND VGND VPWR VPWR sky130_fd_sc_hd__decap_3
XFILLER_100_162 VGND VGND VPWR VPWR sky130_fd_sc_hd__fill_1
XFILLER_100_195 VGND VGND VPWR VPWR sky130_fd_sc_hd__fill_1
XFILLER_46_227 VGND VGND VPWR VPWR sky130_fd_sc_hd__decap_3
XFILLER_74_536 VGND VGND VPWR VPWR sky130_fd_sc_hd__decap_3
XFILLER_27_463 VGND VGND VPWR VPWR sky130_fd_sc_hd__decap_3
XFILLER_36_32 VGND VGND VPWR VPWR sky130_fd_sc_hd__decap_3
XFILLER_61_208 VGND VGND VPWR VPWR sky130_fd_sc_hd__decap_3
XFILLER_74_569 VGND VGND VPWR VPWR sky130_fd_sc_hd__decap_3
XFILLER_36_65 VGND VGND VPWR VPWR sky130_fd_sc_hd__decap_3
XFILLER_82_580 VGND VGND VPWR VPWR sky130_fd_sc_hd__decap_3
XTAP_TAPCELL_ROW_68_1072 VGND VPWR sky130_fd_sc_hd__tapvpwrvgnd_1
XFILLER_14_135 VGND VGND VPWR VPWR sky130_fd_sc_hd__decap_3
XFILLER_54_293 VGND VGND VPWR VPWR sky130_fd_sc_hd__decap_3
XFILLER_42_477 VGND VGND VPWR VPWR sky130_fd_sc_hd__decap_3
XFILLER_52_64 VGND VGND VPWR VPWR sky130_fd_sc_hd__fill_1
XFILLER_10_363 VGND VGND VPWR VPWR sky130_fd_sc_hd__fill_1
XFILLER_10_374 VGND VGND VPWR VPWR sky130_fd_sc_hd__decap_3
XFILLER_108_240 VGND VGND VPWR VPWR sky130_fd_sc_hd__decap_3
XFILLER_42_9 VGND VGND VPWR VPWR sky130_fd_sc_hd__decap_3
XFILLER_97_617 VGND VGND VPWR VPWR sky130_fd_sc_hd__decap_3
XFILLER_111_405 VGND VGND VPWR VPWR sky130_fd_sc_hd__decap_3
XFILLER_96_127 VGND VGND VPWR VPWR sky130_fd_sc_hd__decap_3
XFILLER_111_438 VGND VGND VPWR VPWR sky130_fd_sc_hd__decap_3
XFILLER_111_449 VGND VGND VPWR VPWR sky130_fd_sc_hd__fill_2
XFILLER_77_72 VGND VGND VPWR VPWR sky130_fd_sc_hd__decap_3
XFILLER_65_514 VGND VGND VPWR VPWR sky130_fd_sc_hd__decap_3
XFILLER_77_352 VGND VGND VPWR VPWR sky130_fd_sc_hd__decap_3
XFILLER_65_525 VGND VGND VPWR VPWR sky130_fd_sc_hd__fill_2
XFILLER_77_396 VGND VGND VPWR VPWR sky130_fd_sc_hd__decap_3
XFILLER_92_333 VGND VGND VPWR VPWR sky130_fd_sc_hd__decap_3
XFILLER_52_208 VGND VGND VPWR VPWR sky130_fd_sc_hd__decap_3
XFILLER_92_355 VGND VGND VPWR VPWR sky130_fd_sc_hd__decap_3
XFILLER_93_60 VGND VGND VPWR VPWR sky130_fd_sc_hd__decap_3
XFILLER_18_496 VGND VGND VPWR VPWR sky130_fd_sc_hd__fill_1
XFILLER_33_411 VGND VGND VPWR VPWR sky130_fd_sc_hd__decap_3
XFILLER_80_539 VGND VGND VPWR VPWR sky130_fd_sc_hd__decap_3
XFILLER_93_82 VGND VGND VPWR VPWR sky130_fd_sc_hd__decap_3
XFILLER_33_422 VGND VGND VPWR VPWR sky130_fd_sc_hd__decap_3
XFILLER_33_444 VGND VGND VPWR VPWR sky130_fd_sc_hd__decap_3
XFILLER_33_455 VGND VGND VPWR VPWR sky130_fd_sc_hd__decap_3
X_4840_ _4903_/B _4903_/C _4903_/A VGND VGND VPWR VPWR _4888_/B sky130_fd_sc_hd__a21oi_2
XFILLER_20_105 VGND VGND VPWR VPWR sky130_fd_sc_hd__decap_3
XFILLER_21_617 VGND VGND VPWR VPWR sky130_fd_sc_hd__decap_3
XFILLER_60_241 VGND VGND VPWR VPWR sky130_fd_sc_hd__decap_3
XFILLER_20_138 VGND VGND VPWR VPWR sky130_fd_sc_hd__fill_2
X_6510_ _6608_/A VGND VGND VPWR VPWR _6510_/Y sky130_fd_sc_hd__inv_2
X_4771_ _4836_/S _7005_/D _4760_/Y _4770_/X VGND VGND VPWR VPWR _4771_/X sky130_fd_sc_hd__o211a_2
XTAP_TAPCELL_ROW_31_623 VGND VPWR sky130_fd_sc_hd__tapvpwrvgnd_1
XFILLER_13_190 VGND VGND VPWR VPWR sky130_fd_sc_hd__decap_3
XFILLER_9_161 VGND VGND VPWR VPWR sky130_fd_sc_hd__decap_3
X_6441_ _6604_/A VGND VGND VPWR VPWR _6441_/Y sky130_fd_sc_hd__inv_2
XFILLER_9_172 VGND VGND VPWR VPWR sky130_fd_sc_hd__decap_3
X_6372_ _6567_/A VGND VGND VPWR VPWR _6372_/Y sky130_fd_sc_hd__inv_2
XTAP_TAPCELL_ROW_11_380 VGND VPWR sky130_fd_sc_hd__tapvpwrvgnd_1
X_5323_ _5323_/A0 _4945_/X _5327_/S VGND VGND VPWR VPWR _7169_/D sky130_fd_sc_hd__mux2_2
X_3584_ _3424_/S _3583_/X _5648_/B VGND VGND VPWR VPWR _3586_/D sky130_fd_sc_hd__a21oi_2
XFILLER_102_405 VGND VGND VPWR VPWR sky130_fd_sc_hd__decap_3
XFILLER_102_427 VGND VGND VPWR VPWR sky130_fd_sc_hd__decap_3
X_4205_ _4205_/A _4205_/B _4205_/C VGND VGND VPWR VPWR _4205_/X sky130_fd_sc_hd__and3_2
XFILLER_110_460 VGND VGND VPWR VPWR sky130_fd_sc_hd__decap_3
XFILLER_68_341 VGND VGND VPWR VPWR sky130_fd_sc_hd__decap_3
XFILLER_68_374 VGND VGND VPWR VPWR sky130_fd_sc_hd__decap_3
X_4136_ _7235_/Q _4469_/A3 _4946_/S _7299_/Q _4135_/X VGND VGND VPWR VPWR _4136_/X
+ sky130_fd_sc_hd__a221o_2
XFILLER_113_26 VGND VGND VPWR VPWR sky130_fd_sc_hd__fill_1
XFILLER_83_333 VGND VGND VPWR VPWR sky130_fd_sc_hd__decap_3
XFILLER_95_160 VGND VGND VPWR VPWR sky130_fd_sc_hd__decap_3
XTAP_TAPCELL_ROW_39_723 VGND VPWR sky130_fd_sc_hd__tapvpwrvgnd_1
XFILLER_113_48 VGND VGND VPWR VPWR sky130_fd_sc_hd__decap_3
XFILLER_73_19 VGND VGND VPWR VPWR sky130_fd_sc_hd__decap_3
XFILLER_83_355 VGND VGND VPWR VPWR sky130_fd_sc_hd__decap_3
X_4067_ _4068_/A _4082_/A VGND VGND VPWR VPWR _4744_/B sky130_fd_sc_hd__and2_2
XFILLER_24_400 VGND VGND VPWR VPWR sky130_fd_sc_hd__decap_3
XFILLER_43_208 VGND VGND VPWR VPWR sky130_fd_sc_hd__fill_2
XFILLER_71_517 VGND VGND VPWR VPWR sky130_fd_sc_hd__fill_1
XFILLER_71_528 VGND VGND VPWR VPWR sky130_fd_sc_hd__decap_3
XFILLER_83_388 VGND VGND VPWR VPWR sky130_fd_sc_hd__decap_3
XFILLER_83_399 VGND VGND VPWR VPWR sky130_fd_sc_hd__decap_3
XTAP_TAPCELL_ROW_104_1504 VGND VPWR sky130_fd_sc_hd__tapvpwrvgnd_1
XFILLER_36_282 VGND VGND VPWR VPWR sky130_fd_sc_hd__decap_3
XTAP_TAPCELL_ROW_19_480 VGND VPWR sky130_fd_sc_hd__tapvpwrvgnd_1
XFILLER_11_105 VGND VGND VPWR VPWR sky130_fd_sc_hd__decap_3
XFILLER_24_477 VGND VGND VPWR VPWR sky130_fd_sc_hd__decap_3
XFILLER_11_116 VGND VGND VPWR VPWR sky130_fd_sc_hd__decap_3
XFILLER_51_296 VGND VGND VPWR VPWR sky130_fd_sc_hd__decap_3
X_4969_ _4968_/Y _4969_/B _4969_/C VGND VGND VPWR VPWR _4969_/X sky130_fd_sc_hd__and3b_2
XFILLER_11_149 VGND VGND VPWR VPWR sky130_fd_sc_hd__decap_3
XFILLER_22_12 VGND VGND VPWR VPWR sky130_fd_sc_hd__decap_3
X_6708_ _7406_/CLK _6708_/D VGND VGND VPWR VPWR _6708_/Q sky130_fd_sc_hd__dfxtp_2
XFILLER_22_56 VGND VGND VPWR VPWR sky130_fd_sc_hd__decap_3
X_6639_ _6639_/A VGND VGND VPWR VPWR _6639_/Y sky130_fd_sc_hd__inv_2
XFILLER_98_16 VGND VGND VPWR VPWR sky130_fd_sc_hd__decap_3
XTAP_TAPCELL_ROW_115_1633 VGND VPWR sky130_fd_sc_hd__tapvpwrvgnd_1
XFILLER_3_337 VGND VGND VPWR VPWR sky130_fd_sc_hd__fill_2
XFILLER_3_348 VGND VGND VPWR VPWR sky130_fd_sc_hd__fill_1
XFILLER_105_254 VGND VGND VPWR VPWR sky130_fd_sc_hd__decap_3
XFILLER_105_287 VGND VGND VPWR VPWR sky130_fd_sc_hd__decap_3
XFILLER_79_617 VGND VGND VPWR VPWR sky130_fd_sc_hd__decap_3
Xoutput480 _5655_/D VGND VGND VPWR VPWR alu_result_out[23] sky130_fd_sc_hd__clkdlybuf4s25_1
Xoutput491 _3735_/A VGND VGND VPWR VPWR alu_result_out[4] sky130_fd_sc_hd__clkdlybuf4s25_1
XPHY_EDGE_ROW_110_Right_110 VGND VGND VPWR VPWR sky130_fd_sc_hd__decap_3
XFILLER_59_352 VGND VGND VPWR VPWR sky130_fd_sc_hd__fill_1
XFILLER_93_119 VGND VGND VPWR VPWR sky130_fd_sc_hd__decap_3
XFILLER_101_471 VGND VGND VPWR VPWR sky130_fd_sc_hd__decap_3
XFILLER_19_216 VGND VGND VPWR VPWR sky130_fd_sc_hd__decap_3
XFILLER_47_42 VGND VGND VPWR VPWR sky130_fd_sc_hd__decap_3
XFILLER_59_374 VGND VGND VPWR VPWR sky130_fd_sc_hd__decap_3
XFILLER_59_396 VGND VGND VPWR VPWR sky130_fd_sc_hd__decap_3
XFILLER_19_249 VGND VGND VPWR VPWR sky130_fd_sc_hd__decap_3
XFILLER_62_517 VGND VGND VPWR VPWR sky130_fd_sc_hd__decap_3
XFILLER_27_293 VGND VGND VPWR VPWR sky130_fd_sc_hd__decap_3
XFILLER_55_591 VGND VGND VPWR VPWR sky130_fd_sc_hd__decap_3
XFILLER_63_74 VGND VGND VPWR VPWR sky130_fd_sc_hd__decap_3
XFILLER_30_436 VGND VGND VPWR VPWR sky130_fd_sc_hd__decap_3
XFILLER_42_296 VGND VGND VPWR VPWR sky130_fd_sc_hd__decap_3
XFILLER_70_583 VGND VGND VPWR VPWR sky130_fd_sc_hd__decap_3
XFILLER_8_14 VGND VGND VPWR VPWR sky130_fd_sc_hd__decap_3
XFILLER_30_469 VGND VGND VPWR VPWR sky130_fd_sc_hd__decap_3
XFILLER_11_661 VGND VGND VPWR VPWR sky130_fd_sc_hd__fill_1
XFILLER_7_621 VGND VGND VPWR VPWR sky130_fd_sc_hd__fill_1
XFILLER_116_519 VGND VGND VPWR VPWR sky130_fd_sc_hd__decap_3
XFILLER_6_175 VGND VGND VPWR VPWR sky130_fd_sc_hd__decap_3
XFILLER_40_6 VGND VGND VPWR VPWR sky130_fd_sc_hd__decap_3
XFILLER_69_105 VGND VGND VPWR VPWR sky130_fd_sc_hd__decap_3
XFILLER_69_116 VGND VGND VPWR VPWR sky130_fd_sc_hd__decap_3
XFILLER_97_414 VGND VGND VPWR VPWR sky130_fd_sc_hd__decap_3
XTAP_TAPCELL_ROW_90_1327 VGND VPWR sky130_fd_sc_hd__tapvpwrvgnd_1
XFILLER_69_149 VGND VGND VPWR VPWR sky130_fd_sc_hd__decap_3
XFILLER_97_447 VGND VGND VPWR VPWR sky130_fd_sc_hd__fill_1
XFILLER_97_458 VGND VGND VPWR VPWR sky130_fd_sc_hd__decap_3
XFILLER_65_322 VGND VGND VPWR VPWR sky130_fd_sc_hd__decap_3
XFILLER_93_620 VGND VGND VPWR VPWR sky130_fd_sc_hd__decap_3
XFILLER_92_130 VGND VGND VPWR VPWR sky130_fd_sc_hd__fill_2
XFILLER_92_141 VGND VGND VPWR VPWR sky130_fd_sc_hd__decap_3
X_6990_ _7393_/CLK _6990_/D _6270_/Y VGND VGND VPWR VPWR _6990_/Q sky130_fd_sc_hd__dfrtp_2
XFILLER_25_208 VGND VGND VPWR VPWR sky130_fd_sc_hd__decap_3
XFILLER_65_399 VGND VGND VPWR VPWR sky130_fd_sc_hd__decap_3
XFILLER_92_185 VGND VGND VPWR VPWR sky130_fd_sc_hd__decap_3
XFILLER_18_271 VGND VGND VPWR VPWR sky130_fd_sc_hd__decap_3
XFILLER_80_336 VGND VGND VPWR VPWR sky130_fd_sc_hd__decap_3
XFILLER_33_263 VGND VGND VPWR VPWR sky130_fd_sc_hd__decap_3
XFILLER_61_561 VGND VGND VPWR VPWR sky130_fd_sc_hd__decap_3
X_4823_ _4823_/A0 _4822_/X _4879_/S VGND VGND VPWR VPWR _7272_/D sky130_fd_sc_hd__mux2_2
XTAP_TAPCELL_ROW_44_781 VGND VPWR sky130_fd_sc_hd__tapvpwrvgnd_1
XFILLER_21_447 VGND VGND VPWR VPWR sky130_fd_sc_hd__fill_1
X_3705_ _7400_/Q _3704_/X _4832_/A VGND VGND VPWR VPWR _7400_/D sky130_fd_sc_hd__mux2_2
XFILLER_107_519 VGND VGND VPWR VPWR sky130_fd_sc_hd__decap_3
X_4685_ _6996_/Q _4668_/X _4928_/B _4684_/X VGND VGND VPWR VPWR _4858_/B sky130_fd_sc_hd__a31o_2
XFILLER_108_15 VGND VGND VPWR VPWR sky130_fd_sc_hd__decap_3
X_6424_ _6675_/A VGND VGND VPWR VPWR _6424_/Y sky130_fd_sc_hd__inv_2
X_3636_ _3636_/A _3636_/B VGND VGND VPWR VPWR _3636_/Y sky130_fd_sc_hd__nor2_2
X_6355_ _6385_/A VGND VGND VPWR VPWR _6355_/Y sky130_fd_sc_hd__inv_2
X_3567_ _7221_/Q _4307_/A2 _4532_/S _7034_/Q _3566_/X VGND VGND VPWR VPWR _3567_/X
+ sky130_fd_sc_hd__a221o_2
XFILLER_0_318 VGND VGND VPWR VPWR sky130_fd_sc_hd__decap_3
X_6286_ _6287_/A VGND VGND VPWR VPWR _6286_/Y sky130_fd_sc_hd__inv_2
X_5306_ _5306_/A0 _4806_/X _5325_/S VGND VGND VPWR VPWR _7177_/D sky130_fd_sc_hd__mux2_2
XFILLER_102_235 VGND VGND VPWR VPWR sky130_fd_sc_hd__decap_3
X_3498_ _3442_/A _3442_/B _3449_/B VGND VGND VPWR VPWR _5152_/B sky130_fd_sc_hd__a21oi_2
XFILLER_102_268 VGND VGND VPWR VPWR sky130_fd_sc_hd__decap_3
XFILLER_29_503 VGND VGND VPWR VPWR sky130_fd_sc_hd__fill_1
XFILLER_75_108 VGND VGND VPWR VPWR sky130_fd_sc_hd__decap_3
XTAP_TAPCELL_ROW_110_1574 VGND VPWR sky130_fd_sc_hd__tapvpwrvgnd_1
XFILLER_29_514 VGND VGND VPWR VPWR sky130_fd_sc_hd__fill_2
XFILLER_29_525 VGND VGND VPWR VPWR sky130_fd_sc_hd__fill_1
XFILLER_68_160 VGND VGND VPWR VPWR sky130_fd_sc_hd__fill_2
XFILLER_68_182 VGND VGND VPWR VPWR sky130_fd_sc_hd__decap_3
XFILLER_75_119 VGND VGND VPWR VPWR sky130_fd_sc_hd__fill_1
XFILLER_84_18 VGND VGND VPWR VPWR sky130_fd_sc_hd__decap_3
XFILLER_84_29 VGND VGND VPWR VPWR sky130_fd_sc_hd__fill_1
XFILLER_96_480 VGND VGND VPWR VPWR sky130_fd_sc_hd__decap_3
XFILLER_17_12 VGND VGND VPWR VPWR sky130_fd_sc_hd__decap_3
XFILLER_29_569 VGND VGND VPWR VPWR sky130_fd_sc_hd__fill_1
XFILLER_56_333 VGND VGND VPWR VPWR sky130_fd_sc_hd__decap_3
XFILLER_84_642 VGND VGND VPWR VPWR sky130_fd_sc_hd__fill_2
X_5099_ _5099_/A _5100_/A VGND VGND VPWR VPWR _5099_/X sky130_fd_sc_hd__or2_2
X_4119_ _7236_/Q _4414_/A2 _4196_/A2 _7396_/Q _4118_/X VGND VGND VPWR VPWR _4119_/X
+ sky130_fd_sc_hd__a221o_2
XFILLER_17_45 VGND VGND VPWR VPWR sky130_fd_sc_hd__fill_2
XFILLER_44_517 VGND VGND VPWR VPWR sky130_fd_sc_hd__decap_3
XFILLER_56_377 VGND VGND VPWR VPWR sky130_fd_sc_hd__decap_3
XFILLER_71_358 VGND VGND VPWR VPWR sky130_fd_sc_hd__decap_3
XFILLER_83_185 VGND VGND VPWR VPWR sky130_fd_sc_hd__fill_2
XTAP_TAPCELL_ROW_65_1031 VGND VPWR sky130_fd_sc_hd__tapvpwrvgnd_1
XFILLER_24_230 VGND VGND VPWR VPWR sky130_fd_sc_hd__fill_1
XFILLER_12_447 VGND VGND VPWR VPWR sky130_fd_sc_hd__decap_3
XTAP_TAPCELL_ROW_76_1160 VGND VPWR sky130_fd_sc_hd__tapvpwrvgnd_1
XFILLER_106_563 VGND VGND VPWR VPWR sky130_fd_sc_hd__decap_3
XFILLER_79_414 VGND VGND VPWR VPWR sky130_fd_sc_hd__decap_3
XFILLER_3_189 VGND VGND VPWR VPWR sky130_fd_sc_hd__decap_3
XFILLER_79_447 VGND VGND VPWR VPWR sky130_fd_sc_hd__fill_1
XFILLER_79_458 VGND VGND VPWR VPWR sky130_fd_sc_hd__decap_3
XFILLER_58_41 VGND VGND VPWR VPWR sky130_fd_sc_hd__decap_3
XFILLER_58_74 VGND VGND VPWR VPWR sky130_fd_sc_hd__decap_3
XFILLER_67_609 VGND VGND VPWR VPWR sky130_fd_sc_hd__decap_3
XFILLER_94_406 VGND VGND VPWR VPWR sky130_fd_sc_hd__decap_3
XFILLER_47_311 VGND VGND VPWR VPWR sky130_fd_sc_hd__decap_3
XFILLER_58_85 VGND VGND VPWR VPWR sky130_fd_sc_hd__fill_2
XFILLER_59_182 VGND VGND VPWR VPWR sky130_fd_sc_hd__decap_3
XFILLER_75_620 VGND VGND VPWR VPWR sky130_fd_sc_hd__decap_3
XFILLER_94_439 VGND VGND VPWR VPWR sky130_fd_sc_hd__decap_3
XFILLER_74_141 VGND VGND VPWR VPWR sky130_fd_sc_hd__decap_3
XFILLER_114_80 VGND VGND VPWR VPWR sky130_fd_sc_hd__decap_3
XFILLER_114_91 VGND VGND VPWR VPWR sky130_fd_sc_hd__decap_3
XFILLER_47_377 VGND VGND VPWR VPWR sky130_fd_sc_hd__decap_3
XFILLER_62_303 VGND VGND VPWR VPWR sky130_fd_sc_hd__decap_3
XFILLER_74_174 VGND VGND VPWR VPWR sky130_fd_sc_hd__decap_3
XFILLER_74_40 VGND VGND VPWR VPWR sky130_fd_sc_hd__decap_3
XFILLER_47_399 VGND VGND VPWR VPWR sky130_fd_sc_hd__decap_3
XFILLER_62_347 VGND VGND VPWR VPWR sky130_fd_sc_hd__decap_3
XFILLER_74_62 VGND VGND VPWR VPWR sky130_fd_sc_hd__fill_2
XFILLER_90_645 VGND VGND VPWR VPWR sky130_fd_sc_hd__decap_3
XFILLER_15_252 VGND VGND VPWR VPWR sky130_fd_sc_hd__decap_3
XFILLER_90_678 VGND VGND VPWR VPWR sky130_fd_sc_hd__decap_3
XFILLER_15_296 VGND VGND VPWR VPWR sky130_fd_sc_hd__fill_2
XFILLER_30_211 VGND VGND VPWR VPWR sky130_fd_sc_hd__fill_2
XFILLER_70_380 VGND VGND VPWR VPWR sky130_fd_sc_hd__decap_3
XFILLER_70_391 VGND VGND VPWR VPWR sky130_fd_sc_hd__decap_3
XTAP_TAPCELL_ROW_41_740 VGND VPWR sky130_fd_sc_hd__tapvpwrvgnd_1
XFILLER_30_277 VGND VGND VPWR VPWR sky130_fd_sc_hd__decap_3
XFILLER_90_83 VGND VGND VPWR VPWR sky130_fd_sc_hd__fill_1
XFILLER_90_94 VGND VGND VPWR VPWR sky130_fd_sc_hd__decap_3
XFILLER_116_327 VGND VGND VPWR VPWR sky130_fd_sc_hd__decap_3
X_4470_ _3346_/A _3927_/X _4466_/Y _4469_/X VGND VGND VPWR VPWR _4470_/X sky130_fd_sc_hd__a31o_2
X_3421_ _4537_/B _3421_/B _3421_/C VGND VGND VPWR VPWR _4289_/B sky130_fd_sc_hd__or3_4
X_3352_ _3420_/A _5642_/B VGND VGND VPWR VPWR _3469_/B sky130_fd_sc_hd__nor2_2
XFILLER_112_522 VGND VGND VPWR VPWR sky130_fd_sc_hd__decap_3
XFILLER_112_533 VGND VGND VPWR VPWR sky130_fd_sc_hd__decap_3
XFILLER_112_555 VGND VGND VPWR VPWR sky130_fd_sc_hd__decap_3
XFILLER_85_417 VGND VGND VPWR VPWR sky130_fd_sc_hd__decap_3
XFILLER_97_255 VGND VGND VPWR VPWR sky130_fd_sc_hd__decap_3
XFILLER_57_119 VGND VGND VPWR VPWR sky130_fd_sc_hd__decap_3
XFILLER_97_299 VGND VGND VPWR VPWR sky130_fd_sc_hd__decap_3
Xhold1107 _7270_/Q VGND VGND VPWR VPWR _4865_/A0 sky130_fd_sc_hd__dlygate4sd3_1
Xhold1118 _7339_/Q VGND VGND VPWR VPWR _4480_/A0 sky130_fd_sc_hd__dlygate4sd3_1
Xhold1129 _7397_/Q VGND VGND VPWR VPWR _3754_/A1 sky130_fd_sc_hd__dlygate4sd3_1
X_5022_ _3548_/X _5017_/Y _5020_/X _5021_/X VGND VGND VPWR VPWR _5661_/A sky130_fd_sc_hd__o211a_2
XFILLER_38_344 VGND VGND VPWR VPWR sky130_fd_sc_hd__decap_3
XFILLER_65_130 VGND VGND VPWR VPWR sky130_fd_sc_hd__decap_3
XTAP_TAPCELL_ROW_49_840 VGND VPWR sky130_fd_sc_hd__tapvpwrvgnd_1
XFILLER_53_314 VGND VGND VPWR VPWR sky130_fd_sc_hd__decap_3
XFILLER_81_612 VGND VGND VPWR VPWR sky130_fd_sc_hd__decap_3
XFILLER_81_623 VGND VGND VPWR VPWR sky130_fd_sc_hd__decap_3
XFILLER_65_196 VGND VGND VPWR VPWR sky130_fd_sc_hd__decap_3
X_6973_ _6978_/CLK _6973_/D VGND VGND VPWR VPWR _6973_/Q sky130_fd_sc_hd__dfxtp_2
XFILLER_0_81 VGND VGND VPWR VPWR sky130_fd_sc_hd__decap_3
XFILLER_0_92 VGND VGND VPWR VPWR sky130_fd_sc_hd__decap_3
XFILLER_53_358 VGND VGND VPWR VPWR sky130_fd_sc_hd__fill_2
XFILLER_80_144 VGND VGND VPWR VPWR sky130_fd_sc_hd__decap_3
XFILLER_21_222 VGND VGND VPWR VPWR sky130_fd_sc_hd__fill_2
XFILLER_21_255 VGND VGND VPWR VPWR sky130_fd_sc_hd__decap_3
XFILLER_61_391 VGND VGND VPWR VPWR sky130_fd_sc_hd__fill_1
X_4806_ _3346_/A _3701_/X _4799_/X _4805_/X VGND VGND VPWR VPWR _4806_/X sky130_fd_sc_hd__a31o_2
XFILLER_21_277 VGND VGND VPWR VPWR sky130_fd_sc_hd__decap_3
X_4737_ _7005_/Q _4775_/A _7006_/Q VGND VGND VPWR VPWR _4738_/B sky130_fd_sc_hd__a21oi_2
XFILLER_107_316 VGND VGND VPWR VPWR sky130_fd_sc_hd__decap_3
X_4668_ _4908_/A _4896_/A VGND VGND VPWR VPWR _4668_/X sky130_fd_sc_hd__and2_2
XFILLER_107_349 VGND VGND VPWR VPWR sky130_fd_sc_hd__decap_3
Xhold930 _6712_/Q VGND VGND VPWR VPWR hold930/X sky130_fd_sc_hd__dlygate4sd3_1
X_6407_ _6570_/A VGND VGND VPWR VPWR _6407_/Y sky130_fd_sc_hd__inv_2
X_3619_ _3620_/A _3620_/C _4292_/B VGND VGND VPWR VPWR _3619_/Y sky130_fd_sc_hd__o21ai_2
X_7387_ _7394_/CLK _7387_/D _6667_/Y VGND VGND VPWR VPWR _7387_/Q sky130_fd_sc_hd__dfrtp_2
Xhold941 _6689_/Q VGND VGND VPWR VPWR hold941/X sky130_fd_sc_hd__dlygate4sd3_1
Xhold963 _7024_/Q VGND VGND VPWR VPWR _5607_/A sky130_fd_sc_hd__dlygate4sd3_1
Xhold952 _6691_/Q VGND VGND VPWR VPWR hold952/X sky130_fd_sc_hd__dlygate4sd3_1
X_4599_ _7281_/Q _5142_/A0 _4601_/S VGND VGND VPWR VPWR _7281_/D sky130_fd_sc_hd__mux2_2
XFILLER_0_126 VGND VGND VPWR VPWR sky130_fd_sc_hd__fill_2
XFILLER_88_211 VGND VGND VPWR VPWR sky130_fd_sc_hd__decap_3
Xhold996 _7382_/Q VGND VGND VPWR VPWR hold996/X sky130_fd_sc_hd__dlygate4sd3_1
Xhold985 _7046_/Q VGND VGND VPWR VPWR hold985/X sky130_fd_sc_hd__dlygate4sd3_1
Xhold974 _7390_/Q VGND VGND VPWR VPWR hold974/X sky130_fd_sc_hd__dlygate4sd3_1
X_6338_ _6568_/A VGND VGND VPWR VPWR _6338_/Y sky130_fd_sc_hd__inv_2
XFILLER_0_137 VGND VGND VPWR VPWR sky130_fd_sc_hd__decap_3
XFILLER_103_555 VGND VGND VPWR VPWR sky130_fd_sc_hd__decap_3
XFILLER_88_244 VGND VGND VPWR VPWR sky130_fd_sc_hd__decap_3
XFILLER_95_39 VGND VGND VPWR VPWR sky130_fd_sc_hd__decap_3
X_6269_ _6553_/A VGND VGND VPWR VPWR _6269_/Y sky130_fd_sc_hd__inv_2
XFILLER_103_588 VGND VGND VPWR VPWR sky130_fd_sc_hd__decap_3
XFILLER_48_119 VGND VGND VPWR VPWR sky130_fd_sc_hd__decap_3
XFILLER_57_620 VGND VGND VPWR VPWR sky130_fd_sc_hd__decap_3
XFILLER_69_480 VGND VGND VPWR VPWR sky130_fd_sc_hd__decap_3
XFILLER_28_44 VGND VGND VPWR VPWR sky130_fd_sc_hd__decap_3
XFILLER_28_66 VGND VGND VPWR VPWR sky130_fd_sc_hd__decap_3
XFILLER_28_99 VGND VGND VPWR VPWR sky130_fd_sc_hd__decap_3
XFILLER_44_303 VGND VGND VPWR VPWR sky130_fd_sc_hd__decap_3
XFILLER_56_174 VGND VGND VPWR VPWR sky130_fd_sc_hd__decap_3
XFILLER_84_483 VGND VGND VPWR VPWR sky130_fd_sc_hd__decap_3
XFILLER_29_399 VGND VGND VPWR VPWR sky130_fd_sc_hd__decap_3
XFILLER_44_336 VGND VGND VPWR VPWR sky130_fd_sc_hd__decap_3
XFILLER_71_100 VGND VGND VPWR VPWR sky130_fd_sc_hd__decap_3
XFILLER_72_645 VGND VGND VPWR VPWR sky130_fd_sc_hd__fill_2
XFILLER_25_561 VGND VGND VPWR VPWR sky130_fd_sc_hd__fill_2
XFILLER_32_509 VGND VGND VPWR VPWR sky130_fd_sc_hd__decap_3
XFILLER_44_32 VGND VGND VPWR VPWR sky130_fd_sc_hd__decap_3
XFILLER_71_155 VGND VGND VPWR VPWR sky130_fd_sc_hd__fill_2
XFILLER_71_166 VGND VGND VPWR VPWR sky130_fd_sc_hd__fill_2
XTAP_TAPCELL_ROW_27_578 VGND VPWR sky130_fd_sc_hd__tapvpwrvgnd_1
XFILLER_12_200 VGND VGND VPWR VPWR sky130_fd_sc_hd__decap_3
XFILLER_25_572 VGND VGND VPWR VPWR sky130_fd_sc_hd__fill_1
XFILLER_44_76 VGND VGND VPWR VPWR sky130_fd_sc_hd__decap_3
XFILLER_52_380 VGND VGND VPWR VPWR sky130_fd_sc_hd__fill_1
XFILLER_71_199 VGND VGND VPWR VPWR sky130_fd_sc_hd__decap_3
XFILLER_100_82 VGND VGND VPWR VPWR sky130_fd_sc_hd__fill_2
XFILLER_12_277 VGND VGND VPWR VPWR sky130_fd_sc_hd__decap_3
XFILLER_8_226 VGND VGND VPWR VPWR sky130_fd_sc_hd__decap_3
XFILLER_60_64 VGND VGND VPWR VPWR sky130_fd_sc_hd__decap_3
XFILLER_8_259 VGND VGND VPWR VPWR sky130_fd_sc_hd__decap_3
XFILLER_60_97 VGND VGND VPWR VPWR sky130_fd_sc_hd__decap_3
XFILLER_4_421 VGND VGND VPWR VPWR sky130_fd_sc_hd__fill_1
XFILLER_4_443 VGND VGND VPWR VPWR sky130_fd_sc_hd__decap_3
XFILLER_113_308 VGND VGND VPWR VPWR sky130_fd_sc_hd__decap_3
XFILLER_5_48 VGND VGND VPWR VPWR sky130_fd_sc_hd__decap_3
XFILLER_69_40 VGND VGND VPWR VPWR sky130_fd_sc_hd__decap_3
XFILLER_106_371 VGND VGND VPWR VPWR sky130_fd_sc_hd__decap_3
XFILLER_69_84 VGND VGND VPWR VPWR sky130_fd_sc_hd__decap_3
XFILLER_79_222 VGND VGND VPWR VPWR sky130_fd_sc_hd__fill_2
XFILLER_79_266 VGND VGND VPWR VPWR sky130_fd_sc_hd__decap_3
XFILLER_39_108 VGND VGND VPWR VPWR sky130_fd_sc_hd__decap_3
XFILLER_39_119 VGND VGND VPWR VPWR sky130_fd_sc_hd__decap_3
XFILLER_67_417 VGND VGND VPWR VPWR sky130_fd_sc_hd__decap_3
XFILLER_67_439 VGND VGND VPWR VPWR sky130_fd_sc_hd__decap_3
XFILLER_79_299 VGND VGND VPWR VPWR sky130_fd_sc_hd__fill_1
XFILLER_94_203 VGND VGND VPWR VPWR sky130_fd_sc_hd__decap_3
XFILLER_48_653 VGND VGND VPWR VPWR sky130_fd_sc_hd__fill_2
XFILLER_82_409 VGND VGND VPWR VPWR sky130_fd_sc_hd__decap_3
XFILLER_94_247 VGND VGND VPWR VPWR sky130_fd_sc_hd__decap_3
XPHY_EDGE_ROW_13_Right_13 VGND VGND VPWR VPWR sky130_fd_sc_hd__decap_3
XFILLER_47_141 VGND VGND VPWR VPWR sky130_fd_sc_hd__fill_1
XFILLER_47_152 VGND VGND VPWR VPWR sky130_fd_sc_hd__decap_3
XFILLER_63_612 VGND VGND VPWR VPWR sky130_fd_sc_hd__decap_3
XFILLER_75_461 VGND VGND VPWR VPWR sky130_fd_sc_hd__decap_3
XFILLER_85_72 VGND VGND VPWR VPWR sky130_fd_sc_hd__decap_3
XFILLER_47_196 VGND VGND VPWR VPWR sky130_fd_sc_hd__decap_3
XFILLER_62_111 VGND VGND VPWR VPWR sky130_fd_sc_hd__decap_3
XFILLER_62_122 VGND VGND VPWR VPWR sky130_fd_sc_hd__decap_3
XFILLER_75_494 VGND VGND VPWR VPWR sky130_fd_sc_hd__decap_3
XFILLER_35_369 VGND VGND VPWR VPWR sky130_fd_sc_hd__fill_2
XFILLER_50_306 VGND VGND VPWR VPWR sky130_fd_sc_hd__fill_2
XFILLER_62_166 VGND VGND VPWR VPWR sky130_fd_sc_hd__decap_3
XFILLER_90_464 VGND VGND VPWR VPWR sky130_fd_sc_hd__decap_3
X_3970_ _7355_/Q _4513_/A0 _3989_/S VGND VGND VPWR VPWR _7355_/D sky130_fd_sc_hd__mux2_2
XFILLER_43_380 VGND VGND VPWR VPWR sky130_fd_sc_hd__decap_3
XFILLER_50_339 VGND VGND VPWR VPWR sky130_fd_sc_hd__decap_3
XFILLER_62_188 VGND VGND VPWR VPWR sky130_fd_sc_hd__decap_3
XFILLER_31_564 VGND VGND VPWR VPWR sky130_fd_sc_hd__decap_3
XFILLER_86_3 VGND VGND VPWR VPWR sky130_fd_sc_hd__fill_1
X_5640_ _5642_/A _5640_/B VGND VGND VPWR VPWR _5640_/Y sky130_fd_sc_hd__nor2_2
X_5571_ hold985/X _4960_/A _4944_/C VGND VGND VPWR VPWR _7046_/D sky130_fd_sc_hd__a21o_2
XPHY_EDGE_ROW_22_Right_22 VGND VGND VPWR VPWR sky130_fd_sc_hd__decap_3
XFILLER_116_113 VGND VGND VPWR VPWR sky130_fd_sc_hd__decap_3
X_7310_ _7403_/CLK _7310_/D _6590_/Y VGND VGND VPWR VPWR _7310_/Q sky130_fd_sc_hd__dfrtp_2
X_4522_ _7318_/Q _7286_/Q _4522_/S VGND VGND VPWR VPWR _7318_/D sky130_fd_sc_hd__mux2_2
XFILLER_7_281 VGND VGND VPWR VPWR sky130_fd_sc_hd__decap_3
X_7241_ _7307_/CLK _7241_/D _6521_/Y VGND VGND VPWR VPWR _7241_/Q sky130_fd_sc_hd__dfrtp_2
X_4453_ _4453_/A VGND VGND VPWR VPWR _4762_/B sky130_fd_sc_hd__inv_2
XTAP_TAPCELL_ROW_96_1399 VGND VPWR sky130_fd_sc_hd__tapvpwrvgnd_1
X_7172_ _7362_/CLK _7172_/D _6452_/Y VGND VGND VPWR VPWR _7172_/Q sky130_fd_sc_hd__dfrtp_2
X_4384_ _4384_/A _4968_/A _4384_/C VGND VGND VPWR VPWR _4778_/B sky130_fd_sc_hd__nand3_2
XFILLER_98_542 VGND VGND VPWR VPWR sky130_fd_sc_hd__decap_3
XFILLER_98_531 VGND VGND VPWR VPWR sky130_fd_sc_hd__fill_1
XFILLER_112_341 VGND VGND VPWR VPWR sky130_fd_sc_hd__decap_3
X_3335_ _3319_/X _5238_/B _3329_/Y _3339_/C1 VGND VGND VPWR VPWR _3442_/A sky130_fd_sc_hd__a211o_2
XFILLER_98_575 VGND VGND VPWR VPWR sky130_fd_sc_hd__decap_3
XFILLER_100_503 VGND VGND VPWR VPWR sky130_fd_sc_hd__decap_3
XFILLER_112_374 VGND VGND VPWR VPWR sky130_fd_sc_hd__decap_3
XFILLER_58_439 VGND VGND VPWR VPWR sky130_fd_sc_hd__decap_3
XFILLER_85_203 VGND VGND VPWR VPWR sky130_fd_sc_hd__decap_3
XPHY_EDGE_ROW_31_Right_31 VGND VGND VPWR VPWR sky130_fd_sc_hd__decap_3
XFILLER_38_130 VGND VGND VPWR VPWR sky130_fd_sc_hd__decap_3
X_5005_ _5004_/A _5004_/B _5020_/A VGND VGND VPWR VPWR _5005_/Y sky130_fd_sc_hd__a21oi_2
XFILLER_38_141 VGND VGND VPWR VPWR sky130_fd_sc_hd__decap_3
XFILLER_85_269 VGND VGND VPWR VPWR sky130_fd_sc_hd__fill_2
XFILLER_26_347 VGND VGND VPWR VPWR sky130_fd_sc_hd__decap_3
XFILLER_38_174 VGND VGND VPWR VPWR sky130_fd_sc_hd__decap_3
XFILLER_53_111 VGND VGND VPWR VPWR sky130_fd_sc_hd__fill_1
XFILLER_54_634 VGND VGND VPWR VPWR sky130_fd_sc_hd__fill_1
XFILLER_66_483 VGND VGND VPWR VPWR sky130_fd_sc_hd__fill_1
XFILLER_81_431 VGND VGND VPWR VPWR sky130_fd_sc_hd__decap_3
XFILLER_53_133 VGND VGND VPWR VPWR sky130_fd_sc_hd__decap_3
XFILLER_81_464 VGND VGND VPWR VPWR sky130_fd_sc_hd__decap_3
X_6956_ _6968_/CLK _6956_/D VGND VGND VPWR VPWR _6956_/Q sky130_fd_sc_hd__dfxtp_2
XFILLER_81_19 VGND VGND VPWR VPWR sky130_fd_sc_hd__decap_3
XFILLER_81_497 VGND VGND VPWR VPWR sky130_fd_sc_hd__decap_3
XTAP_TAPCELL_ROW_62_1001 VGND VPWR sky130_fd_sc_hd__tapvpwrvgnd_1
XFILLER_14_35 VGND VGND VPWR VPWR sky130_fd_sc_hd__decap_3
XFILLER_22_531 VGND VGND VPWR VPWR sky130_fd_sc_hd__fill_1
X_6887_ _7198_/CLK _6887_/D VGND VGND VPWR VPWR _6887_/Q sky130_fd_sc_hd__dfxtp_2
XTAP_TAPCELL_ROW_24_537 VGND VPWR sky130_fd_sc_hd__tapvpwrvgnd_1
XFILLER_14_68 VGND VGND VPWR VPWR sky130_fd_sc_hd__decap_3
XTAP_TAPCELL_ROW_52_879 VGND VPWR sky130_fd_sc_hd__tapvpwrvgnd_1
XPHY_EDGE_ROW_40_Right_40 VGND VGND VPWR VPWR sky130_fd_sc_hd__decap_3
XFILLER_107_102 VGND VGND VPWR VPWR sky130_fd_sc_hd__fill_1
XFILLER_107_113 VGND VGND VPWR VPWR sky130_fd_sc_hd__decap_3
XFILLER_30_67 VGND VGND VPWR VPWR sky130_fd_sc_hd__decap_3
Xhold760 _6772_/Q VGND VGND VPWR VPWR _6772_/D sky130_fd_sc_hd__dlygate4sd3_1
Xhold771 _6765_/Q VGND VGND VPWR VPWR _6765_/D sky130_fd_sc_hd__dlygate4sd3_1
Xhold782 _6889_/Q VGND VGND VPWR VPWR _6889_/D sky130_fd_sc_hd__dlygate4sd3_1
XTAP_TAPCELL_ROW_73_1130 VGND VPWR sky130_fd_sc_hd__tapvpwrvgnd_1
XFILLER_103_352 VGND VGND VPWR VPWR sky130_fd_sc_hd__decap_3
XFILLER_89_564 VGND VGND VPWR VPWR sky130_fd_sc_hd__fill_2
Xhold793 _6975_/Q VGND VGND VPWR VPWR _6975_/D sky130_fd_sc_hd__dlygate4sd3_1
XFILLER_103_385 VGND VGND VPWR VPWR sky130_fd_sc_hd__decap_3
XFILLER_49_428 VGND VGND VPWR VPWR sky130_fd_sc_hd__decap_3
XFILLER_39_87 VGND VGND VPWR VPWR sky130_fd_sc_hd__decap_3
XFILLER_76_247 VGND VGND VPWR VPWR sky130_fd_sc_hd__decap_3
XFILLER_29_152 VGND VGND VPWR VPWR sky130_fd_sc_hd__decap_3
XFILLER_57_461 VGND VGND VPWR VPWR sky130_fd_sc_hd__decap_3
XFILLER_29_196 VGND VGND VPWR VPWR sky130_fd_sc_hd__decap_3
XFILLER_44_122 VGND VGND VPWR VPWR sky130_fd_sc_hd__decap_3
XFILLER_55_31 VGND VGND VPWR VPWR sky130_fd_sc_hd__decap_3
XFILLER_57_483 VGND VGND VPWR VPWR sky130_fd_sc_hd__decap_3
XFILLER_84_291 VGND VGND VPWR VPWR sky130_fd_sc_hd__decap_3
XFILLER_91_228 VGND VGND VPWR VPWR sky130_fd_sc_hd__decap_3
XTAP_TAPCELL_ROW_4_295 VGND VPWR sky130_fd_sc_hd__tapvpwrvgnd_1
XFILLER_55_86 VGND VGND VPWR VPWR sky130_fd_sc_hd__decap_3
XFILLER_72_442 VGND VGND VPWR VPWR sky130_fd_sc_hd__decap_3
XFILLER_32_317 VGND VGND VPWR VPWR sky130_fd_sc_hd__decap_3
XFILLER_44_166 VGND VGND VPWR VPWR sky130_fd_sc_hd__decap_3
XFILLER_60_626 VGND VGND VPWR VPWR sky130_fd_sc_hd__fill_1
XFILLER_72_475 VGND VGND VPWR VPWR sky130_fd_sc_hd__fill_1
XFILLER_111_81 VGND VGND VPWR VPWR sky130_fd_sc_hd__decap_3
XFILLER_25_391 VGND VGND VPWR VPWR sky130_fd_sc_hd__fill_1
XFILLER_71_41 VGND VGND VPWR VPWR sky130_fd_sc_hd__decap_3
XFILLER_71_63 VGND VGND VPWR VPWR sky130_fd_sc_hd__decap_3
XFILLER_9_502 VGND VGND VPWR VPWR sky130_fd_sc_hd__fill_2
XFILLER_40_383 VGND VGND VPWR VPWR sky130_fd_sc_hd__fill_2
XFILLER_72_9 VGND VGND VPWR VPWR sky130_fd_sc_hd__decap_3
XFILLER_113_105 VGND VGND VPWR VPWR sky130_fd_sc_hd__fill_2
XFILLER_113_116 VGND VGND VPWR VPWR sky130_fd_sc_hd__decap_3
XFILLER_4_273 VGND VGND VPWR VPWR sky130_fd_sc_hd__decap_3
XFILLER_67_225 VGND VGND VPWR VPWR sky130_fd_sc_hd__decap_3
XFILLER_95_523 VGND VGND VPWR VPWR sky130_fd_sc_hd__decap_3
XFILLER_96_71 VGND VGND VPWR VPWR sky130_fd_sc_hd__decap_3
XFILLER_95_556 VGND VGND VPWR VPWR sky130_fd_sc_hd__decap_3
XFILLER_95_567 VGND VGND VPWR VPWR sky130_fd_sc_hd__decap_3
XFILLER_55_409 VGND VGND VPWR VPWR sky130_fd_sc_hd__decap_3
XFILLER_82_206 VGND VGND VPWR VPWR sky130_fd_sc_hd__decap_3
XFILLER_36_623 VGND VGND VPWR VPWR sky130_fd_sc_hd__fill_2
XFILLER_36_645 VGND VGND VPWR VPWR sky130_fd_sc_hd__fill_2
XFILLER_48_483 VGND VGND VPWR VPWR sky130_fd_sc_hd__fill_1
XFILLER_63_420 VGND VGND VPWR VPWR sky130_fd_sc_hd__decap_3
Xplace420 _3376_/Y VGND VGND VPWR VPWR _5161_/A sky130_fd_sc_hd__buf_2
Xplace431 _3994_/S VGND VGND VPWR VPWR _3989_/S sky130_fd_sc_hd__buf_2
X_6810_ _6967_/CLK _6810_/D VGND VGND VPWR VPWR _6810_/Q sky130_fd_sc_hd__dfxtp_2
XFILLER_51_615 VGND VGND VPWR VPWR sky130_fd_sc_hd__fill_1
XFILLER_90_283 VGND VGND VPWR VPWR sky130_fd_sc_hd__decap_3
Xplace442 _5577_/S VGND VGND VPWR VPWR _5595_/B sky130_fd_sc_hd__buf_2
Xplace453 _3332_/B VGND VGND VPWR VPWR _3318_/B sky130_fd_sc_hd__buf_2
Xplace464 _6979_/Q VGND VGND VPWR VPWR _5129_/B sky130_fd_sc_hd__buf_2
X_6741_ _6976_/CLK _6741_/D VGND VGND VPWR VPWR _6741_/Q sky130_fd_sc_hd__dfxtp_2
X_6672_ _6672_/A VGND VGND VPWR VPWR _6672_/Y sky130_fd_sc_hd__inv_2
X_3884_ _6824_/Q _3912_/A2 _3913_/B1 _6809_/Q _3883_/X VGND VGND VPWR VPWR _3884_/X
+ sky130_fd_sc_hd__a221o_2
XTAP_TAPCELL_ROW_21_507 VGND VPWR sky130_fd_sc_hd__tapvpwrvgnd_1
XTAP_TAPCELL_ROW_98_1428 VGND VPWR sky130_fd_sc_hd__tapvpwrvgnd_1
X_4505_ _4505_/A0 _7295_/Q _4505_/S VGND VGND VPWR VPWR _4505_/X sky130_fd_sc_hd__mux2_2
X_7224_ clkload8/A _7224_/D _6504_/Y VGND VGND VPWR VPWR _7224_/Q sky130_fd_sc_hd__dfrtp_2
X_4436_ _7303_/Q _4879_/S _4436_/B1 _7175_/Q _4435_/X VGND VGND VPWR VPWR _4436_/X
+ sky130_fd_sc_hd__a221o_2
XFILLER_104_138 VGND VGND VPWR VPWR sky130_fd_sc_hd__fill_2
XFILLER_113_650 VGND VGND VPWR VPWR sky130_fd_sc_hd__fill_1
X_7155_ clkload8/A _7155_/D _6435_/Y VGND VGND VPWR VPWR _7155_/Q sky130_fd_sc_hd__dfrtp_2
X_4367_ _4367_/A _4367_/B _4367_/C VGND VGND VPWR VPWR _5054_/A sky130_fd_sc_hd__and3_2
XFILLER_58_203 VGND VGND VPWR VPWR sky130_fd_sc_hd__decap_3
X_3318_ _3362_/A _3318_/B VGND VGND VPWR VPWR _5647_/B sky130_fd_sc_hd__nand2_2
XFILLER_98_383 VGND VGND VPWR VPWR sky130_fd_sc_hd__decap_3
XFILLER_98_361 VGND VGND VPWR VPWR sky130_fd_sc_hd__decap_3
XFILLER_58_236 VGND VGND VPWR VPWR sky130_fd_sc_hd__decap_3
XFILLER_86_545 VGND VGND VPWR VPWR sky130_fd_sc_hd__decap_3
X_7086_ _7362_/CLK _7086_/D _6366_/Y VGND VGND VPWR VPWR _7086_/Q sky130_fd_sc_hd__dfrtp_2
X_4298_ _3620_/C _4292_/X _4293_/X _4297_/Y VGND VGND VPWR VPWR _4298_/X sky130_fd_sc_hd__a211o_2
XFILLER_100_377 VGND VGND VPWR VPWR sky130_fd_sc_hd__decap_3
XFILLER_46_409 VGND VGND VPWR VPWR sky130_fd_sc_hd__decap_3
XFILLER_86_589 VGND VGND VPWR VPWR sky130_fd_sc_hd__decap_3
XFILLER_73_228 VGND VGND VPWR VPWR sky130_fd_sc_hd__decap_3
XTAP_TAPCELL_ROW_57_938 VGND VPWR sky130_fd_sc_hd__tapvpwrvgnd_1
XFILLER_25_12 VGND VGND VPWR VPWR sky130_fd_sc_hd__fill_1
XFILLER_26_133 VGND VGND VPWR VPWR sky130_fd_sc_hd__decap_3
XFILLER_26_144 VGND VGND VPWR VPWR sky130_fd_sc_hd__fill_1
XFILLER_54_442 VGND VGND VPWR VPWR sky130_fd_sc_hd__decap_3
XFILLER_92_29 VGND VGND VPWR VPWR sky130_fd_sc_hd__decap_3
XTAP_TAPCELL_ROW_1_265 VGND VPWR sky130_fd_sc_hd__tapvpwrvgnd_1
XTAP_TAPCELL_ROW_107_1535 VGND VPWR sky130_fd_sc_hd__tapvpwrvgnd_1
XFILLER_25_45 VGND VGND VPWR VPWR sky130_fd_sc_hd__decap_3
XFILLER_26_188 VGND VGND VPWR VPWR sky130_fd_sc_hd__decap_3
XFILLER_54_486 VGND VGND VPWR VPWR sky130_fd_sc_hd__decap_3
XFILLER_25_78 VGND VGND VPWR VPWR sky130_fd_sc_hd__decap_3
XFILLER_41_125 VGND VGND VPWR VPWR sky130_fd_sc_hd__decap_3
XFILLER_41_147 VGND VGND VPWR VPWR sky130_fd_sc_hd__decap_3
X_6939_ _6966_/CLK _6939_/D VGND VGND VPWR VPWR _6939_/Q sky130_fd_sc_hd__dfxtp_2
XTAP_TAPCELL_ROW_37_695 VGND VPWR sky130_fd_sc_hd__tapvpwrvgnd_1
XFILLER_41_169 VGND VGND VPWR VPWR sky130_fd_sc_hd__decap_3
XFILLER_22_383 VGND VGND VPWR VPWR sky130_fd_sc_hd__decap_3
XFILLER_41_11 VGND VGND VPWR VPWR sky130_fd_sc_hd__decap_3
XFILLER_41_55 VGND VGND VPWR VPWR sky130_fd_sc_hd__fill_1
XFILLER_41_66 VGND VGND VPWR VPWR sky130_fd_sc_hd__decap_3
XFILLER_10_589 VGND VGND VPWR VPWR sky130_fd_sc_hd__fill_1
XFILLER_108_477 VGND VGND VPWR VPWR sky130_fd_sc_hd__decap_3
XFILLER_111_609 VGND VGND VPWR VPWR sky130_fd_sc_hd__decap_3
XFILLER_96_309 VGND VGND VPWR VPWR sky130_fd_sc_hd__decap_3
Xhold590 _6896_/Q VGND VGND VPWR VPWR _6896_/D sky130_fd_sc_hd__dlygate4sd3_1
XTAP_TAPCELL_ROW_9_365 VGND VPWR sky130_fd_sc_hd__tapvpwrvgnd_1
XTAP_TAPCELL_ROW_9_354 VGND VPWR sky130_fd_sc_hd__tapvpwrvgnd_1
XFILLER_1_276 VGND VGND VPWR VPWR sky130_fd_sc_hd__fill_1
XFILLER_49_203 VGND VGND VPWR VPWR sky130_fd_sc_hd__decap_3
XFILLER_77_523 VGND VGND VPWR VPWR sky130_fd_sc_hd__decap_3
XFILLER_103_193 VGND VGND VPWR VPWR sky130_fd_sc_hd__decap_3
XFILLER_2_27 VGND VGND VPWR VPWR sky130_fd_sc_hd__fill_1
XFILLER_49_225 VGND VGND VPWR VPWR sky130_fd_sc_hd__decap_3
XFILLER_49_247 VGND VGND VPWR VPWR sky130_fd_sc_hd__decap_3
XFILLER_37_409 VGND VGND VPWR VPWR sky130_fd_sc_hd__fill_1
XFILLER_49_269 VGND VGND VPWR VPWR sky130_fd_sc_hd__decap_3
XFILLER_77_589 VGND VGND VPWR VPWR sky130_fd_sc_hd__decap_3
XFILLER_92_504 VGND VGND VPWR VPWR sky130_fd_sc_hd__decap_3
XFILLER_45_420 VGND VGND VPWR VPWR sky130_fd_sc_hd__decap_3
XFILLER_64_217 VGND VGND VPWR VPWR sky130_fd_sc_hd__decap_3
XFILLER_64_228 VGND VGND VPWR VPWR sky130_fd_sc_hd__decap_3
XFILLER_66_74 VGND VGND VPWR VPWR sky130_fd_sc_hd__decap_3
XFILLER_92_548 VGND VGND VPWR VPWR sky130_fd_sc_hd__decap_3
XFILLER_17_122 VGND VGND VPWR VPWR sky130_fd_sc_hd__decap_3
XFILLER_45_442 VGND VGND VPWR VPWR sky130_fd_sc_hd__decap_3
XFILLER_45_464 VGND VGND VPWR VPWR sky130_fd_sc_hd__decap_3
XFILLER_60_412 VGND VGND VPWR VPWR sky130_fd_sc_hd__decap_3
XFILLER_17_199 VGND VGND VPWR VPWR sky130_fd_sc_hd__decap_3
XFILLER_32_136 VGND VGND VPWR VPWR sky130_fd_sc_hd__decap_3
XFILLER_32_147 VGND VGND VPWR VPWR sky130_fd_sc_hd__decap_3
XFILLER_60_445 VGND VGND VPWR VPWR sky130_fd_sc_hd__decap_3
XFILLER_82_62 VGND VGND VPWR VPWR sky130_fd_sc_hd__decap_3
XFILLER_20_309 VGND VGND VPWR VPWR sky130_fd_sc_hd__fill_1
XFILLER_60_489 VGND VGND VPWR VPWR sky130_fd_sc_hd__decap_3
XFILLER_13_372 VGND VGND VPWR VPWR sky130_fd_sc_hd__fill_1
XFILLER_40_180 VGND VGND VPWR VPWR sky130_fd_sc_hd__decap_3
XFILLER_9_343 VGND VGND VPWR VPWR sky130_fd_sc_hd__decap_3
XFILLER_9_376 VGND VGND VPWR VPWR sky130_fd_sc_hd__decap_3
X_5270_ _5270_/A0 _5040_/X _5274_/S VGND VGND VPWR VPWR _7195_/D sky130_fd_sc_hd__mux2_2
XFILLER_102_609 VGND VGND VPWR VPWR sky130_fd_sc_hd__decap_3
XFILLER_114_458 VGND VGND VPWR VPWR sky130_fd_sc_hd__fill_2
XFILLER_49_3 VGND VGND VPWR VPWR sky130_fd_sc_hd__fill_2
X_4221_ _7228_/Q _4469_/A3 _4510_/S _7041_/Q _4220_/X VGND VGND VPWR VPWR _4221_/X
+ sky130_fd_sc_hd__a221o_2
XTAP_TAPCELL_ROW_93_1369 VGND VPWR sky130_fd_sc_hd__tapvpwrvgnd_1
XFILLER_101_108 VGND VGND VPWR VPWR sky130_fd_sc_hd__decap_3
XFILLER_101_119 VGND VGND VPWR VPWR sky130_fd_sc_hd__fill_2
XFILLER_68_523 VGND VGND VPWR VPWR sky130_fd_sc_hd__fill_1
XFILLER_110_631 VGND VGND VPWR VPWR sky130_fd_sc_hd__fill_1
XFILLER_68_545 VGND VGND VPWR VPWR sky130_fd_sc_hd__decap_3
X_4152_ _7106_/Q _4218_/A2 _4195_/A2 _7138_/Q VGND VGND VPWR VPWR _4152_/X sky130_fd_sc_hd__a22o_2
XFILLER_110_686 VGND VGND VPWR VPWR sky130_fd_sc_hd__decap_3
XFILLER_28_409 VGND VGND VPWR VPWR sky130_fd_sc_hd__decap_3
XFILLER_68_578 VGND VGND VPWR VPWR sky130_fd_sc_hd__decap_3
XFILLER_68_589 VGND VGND VPWR VPWR sky130_fd_sc_hd__fill_1
XFILLER_95_375 VGND VGND VPWR VPWR sky130_fd_sc_hd__decap_3
X_4083_ _7366_/Q _4419_/B1 _3366_/X _7174_/Q VGND VGND VPWR VPWR _4083_/X sky130_fd_sc_hd__a22o_2
XFILLER_55_228 VGND VGND VPWR VPWR sky130_fd_sc_hd__decap_3
XFILLER_83_526 VGND VGND VPWR VPWR sky130_fd_sc_hd__decap_3
XFILLER_48_291 VGND VGND VPWR VPWR sky130_fd_sc_hd__decap_3
XFILLER_24_637 VGND VGND VPWR VPWR sky130_fd_sc_hd__decap_3
XFILLER_91_570 VGND VGND VPWR VPWR sky130_fd_sc_hd__decap_3
XFILLER_23_125 VGND VGND VPWR VPWR sky130_fd_sc_hd__decap_3
Xplace272 _3881_/B1 VGND VGND VPWR VPWR _3912_/B1 sky130_fd_sc_hd__buf_2
X_4985_ _4620_/A _5032_/A _5031_/B _4630_/X VGND VGND VPWR VPWR _5003_/B sky130_fd_sc_hd__a31o_2
XFILLER_23_158 VGND VGND VPWR VPWR sky130_fd_sc_hd__fill_1
XFILLER_23_169 VGND VGND VPWR VPWR sky130_fd_sc_hd__decap_3
XFILLER_51_467 VGND VGND VPWR VPWR sky130_fd_sc_hd__decap_3
Xplace294 _3651_/Y VGND VGND VPWR VPWR _3853_/A2 sky130_fd_sc_hd__buf_2
Xplace283 _3892_/A2 VGND VGND VPWR VPWR _3890_/A2 sky130_fd_sc_hd__buf_2
X_6724_ _6976_/CLK _6724_/D VGND VGND VPWR VPWR _6724_/Q sky130_fd_sc_hd__dfxtp_2
XTAP_TAPCELL_ROW_34_665 VGND VPWR sky130_fd_sc_hd__tapvpwrvgnd_1
XTAP_TAPCELL_ROW_34_654 VGND VPWR sky130_fd_sc_hd__tapvpwrvgnd_1
XFILLER_32_681 VGND VGND VPWR VPWR sky130_fd_sc_hd__fill_1
XTAP_TAPCELL_ROW_62_996 VGND VPWR sky130_fd_sc_hd__tapvpwrvgnd_1
XTAP_TAPCELL_ROW_102_1476 VGND VPWR sky130_fd_sc_hd__tapvpwrvgnd_1
XFILLER_31_191 VGND VGND VPWR VPWR sky130_fd_sc_hd__decap_3
X_6655_ _6670_/A VGND VGND VPWR VPWR _6655_/Y sky130_fd_sc_hd__inv_2
X_3867_ _3629_/Y _3866_/X _5151_/A VGND VGND VPWR VPWR _3867_/X sky130_fd_sc_hd__o21a_2
XFILLER_11_14 VGND VGND VPWR VPWR sky130_fd_sc_hd__decap_3
X_6586_ _6587_/A VGND VGND VPWR VPWR _6586_/Y sky130_fd_sc_hd__inv_2
X_3798_ _6738_/Q _3889_/A2 _3892_/B1 _6744_/Q _3797_/X VGND VGND VPWR VPWR _3798_/X
+ sky130_fd_sc_hd__a221o_2
XFILLER_11_69 VGND VGND VPWR VPWR sky130_fd_sc_hd__fill_2
XFILLER_105_458 VGND VGND VPWR VPWR sky130_fd_sc_hd__decap_3
XFILLER_78_309 VGND VGND VPWR VPWR sky130_fd_sc_hd__decap_3
XFILLER_87_18 VGND VGND VPWR VPWR sky130_fd_sc_hd__decap_3
X_7207_ _7338_/CLK _7207_/D _6487_/Y VGND VGND VPWR VPWR _7207_/Q sky130_fd_sc_hd__dfrtp_2
XFILLER_59_501 VGND VGND VPWR VPWR sky130_fd_sc_hd__decap_3
X_4419_ _7304_/Q _4486_/S _4419_/B1 _7368_/Q _4429_/C1 VGND VGND VPWR VPWR _4419_/X
+ sky130_fd_sc_hd__a221o_2
XTAP_TAPCELL_ROW_6_324 VGND VPWR sky130_fd_sc_hd__tapvpwrvgnd_1
XFILLER_101_620 VGND VGND VPWR VPWR sky130_fd_sc_hd__decap_3
XFILLER_59_523 VGND VGND VPWR VPWR sky130_fd_sc_hd__fill_1
XFILLER_59_545 VGND VGND VPWR VPWR sky130_fd_sc_hd__decap_3
X_7138_ _7362_/CLK _7138_/D _6418_/Y VGND VGND VPWR VPWR _7138_/Q sky130_fd_sc_hd__dfrtp_2
XFILLER_98_191 VGND VGND VPWR VPWR sky130_fd_sc_hd__fill_1
XFILLER_100_141 VGND VGND VPWR VPWR sky130_fd_sc_hd__decap_3
XFILLER_46_206 VGND VGND VPWR VPWR sky130_fd_sc_hd__decap_3
XFILLER_86_342 VGND VGND VPWR VPWR sky130_fd_sc_hd__decap_3
X_7069_ _7364_/CLK _7069_/D _6349_/Y VGND VGND VPWR VPWR _7069_/Q sky130_fd_sc_hd__dfrtp_2
XFILLER_74_548 VGND VGND VPWR VPWR sky130_fd_sc_hd__decap_3
XFILLER_86_386 VGND VGND VPWR VPWR sky130_fd_sc_hd__decap_3
XFILLER_27_442 VGND VGND VPWR VPWR sky130_fd_sc_hd__decap_3
XFILLER_14_103 VGND VGND VPWR VPWR sky130_fd_sc_hd__fill_1
XFILLER_36_88 VGND VGND VPWR VPWR sky130_fd_sc_hd__decap_3
XFILLER_54_272 VGND VGND VPWR VPWR sky130_fd_sc_hd__decap_3
XTAP_TAPCELL_ROW_68_1073 VGND VPWR sky130_fd_sc_hd__tapvpwrvgnd_1
XTAP_TAPCELL_ROW_68_1062 VGND VPWR sky130_fd_sc_hd__tapvpwrvgnd_1
XFILLER_82_592 VGND VGND VPWR VPWR sky130_fd_sc_hd__decap_3
XFILLER_14_147 VGND VGND VPWR VPWR sky130_fd_sc_hd__decap_3
XFILLER_14_158 VGND VGND VPWR VPWR sky130_fd_sc_hd__decap_3
XFILLER_52_21 VGND VGND VPWR VPWR sky130_fd_sc_hd__decap_3
XFILLER_52_32 VGND VGND VPWR VPWR sky130_fd_sc_hd__decap_3
XFILLER_10_342 VGND VGND VPWR VPWR sky130_fd_sc_hd__decap_3
XFILLER_97_607 VGND VGND VPWR VPWR sky130_fd_sc_hd__decap_3
XFILLER_111_417 VGND VGND VPWR VPWR sky130_fd_sc_hd__decap_3
XFILLER_96_106 VGND VGND VPWR VPWR sky130_fd_sc_hd__decap_3
XFILLER_97_629 VGND VGND VPWR VPWR sky130_fd_sc_hd__decap_3
XFILLER_104_480 VGND VGND VPWR VPWR sky130_fd_sc_hd__fill_2
XFILLER_77_331 VGND VGND VPWR VPWR sky130_fd_sc_hd__decap_3
XFILLER_77_40 VGND VGND VPWR VPWR sky130_fd_sc_hd__decap_3
XFILLER_96_139 VGND VGND VPWR VPWR sky130_fd_sc_hd__fill_1
XFILLER_37_206 VGND VGND VPWR VPWR sky130_fd_sc_hd__decap_3
XFILLER_77_364 VGND VGND VPWR VPWR sky130_fd_sc_hd__decap_3
XFILLER_37_228 VGND VGND VPWR VPWR sky130_fd_sc_hd__decap_3
XFILLER_65_537 VGND VGND VPWR VPWR sky130_fd_sc_hd__decap_3
XFILLER_92_312 VGND VGND VPWR VPWR sky130_fd_sc_hd__decap_3
XFILLER_80_507 VGND VGND VPWR VPWR sky130_fd_sc_hd__decap_3
XFILLER_45_250 VGND VGND VPWR VPWR sky130_fd_sc_hd__decap_3
XFILLER_60_220 VGND VGND VPWR VPWR sky130_fd_sc_hd__decap_3
XFILLER_93_94 VGND VGND VPWR VPWR sky130_fd_sc_hd__decap_3
XFILLER_21_607 VGND VGND VPWR VPWR sky130_fd_sc_hd__fill_1
XFILLER_33_467 VGND VGND VPWR VPWR sky130_fd_sc_hd__fill_1
XFILLER_33_478 VGND VGND VPWR VPWR sky130_fd_sc_hd__decap_3
XFILLER_60_253 VGND VGND VPWR VPWR sky130_fd_sc_hd__decap_3
XFILLER_14_670 VGND VGND VPWR VPWR sky130_fd_sc_hd__fill_1
XFILLER_20_117 VGND VGND VPWR VPWR sky130_fd_sc_hd__decap_3
X_4770_ _4832_/A _3692_/X _5663_/A _3509_/B VGND VGND VPWR VPWR _4770_/X sky130_fd_sc_hd__a211o_2
XTAP_TAPCELL_ROW_31_624 VGND VPWR sky130_fd_sc_hd__tapvpwrvgnd_1
X_3721_ _6863_/Q _3889_/A2 _3913_/B1 _6855_/Q _3720_/X VGND VGND VPWR VPWR _3721_/X
+ sky130_fd_sc_hd__a221o_2
XFILLER_9_140 VGND VGND VPWR VPWR sky130_fd_sc_hd__decap_3
X_6440_ _6532_/A VGND VGND VPWR VPWR _6440_/Y sky130_fd_sc_hd__inv_2
XFILLER_9_184 VGND VGND VPWR VPWR sky130_fd_sc_hd__decap_3
X_6371_ _6567_/A VGND VGND VPWR VPWR _6371_/Y sky130_fd_sc_hd__inv_2
X_3583_ _3583_/A _3583_/B _3583_/C VGND VGND VPWR VPWR _3583_/X sky130_fd_sc_hd__or3_4
XTAP_TAPCELL_ROW_11_381 VGND VPWR sky130_fd_sc_hd__tapvpwrvgnd_1
X_5253_ _5253_/A0 _4913_/X _5262_/S VGND VGND VPWR VPWR _7203_/D sky130_fd_sc_hd__mux2_2
XFILLER_96_640 VGND VGND VPWR VPWR sky130_fd_sc_hd__decap_3
X_5184_ _5184_/A _5194_/B VGND VGND VPWR VPWR _7236_/D sky130_fd_sc_hd__and2_2
X_4204_ _4936_/A _4201_/X _4203_/X VGND VGND VPWR VPWR _4204_/Y sky130_fd_sc_hd__o21bai_2
XFILLER_56_504 VGND VGND VPWR VPWR sky130_fd_sc_hd__decap_3
XFILLER_68_353 VGND VGND VPWR VPWR sky130_fd_sc_hd__decap_3
X_4135_ _7107_/Q _4218_/A2 _4195_/A2 _7139_/Q VGND VGND VPWR VPWR _4135_/X sky130_fd_sc_hd__a22o_2
XFILLER_110_472 VGND VGND VPWR VPWR sky130_fd_sc_hd__decap_3
XFILLER_28_206 VGND VGND VPWR VPWR sky130_fd_sc_hd__decap_3
XFILLER_28_228 VGND VGND VPWR VPWR sky130_fd_sc_hd__decap_3
XFILLER_56_526 VGND VGND VPWR VPWR sky130_fd_sc_hd__decap_3
XFILLER_68_386 VGND VGND VPWR VPWR sky130_fd_sc_hd__decap_3
XFILLER_83_312 VGND VGND VPWR VPWR sky130_fd_sc_hd__decap_3
XTAP_TAPCELL_ROW_39_724 VGND VPWR sky130_fd_sc_hd__tapvpwrvgnd_1
XFILLER_83_367 VGND VGND VPWR VPWR sky130_fd_sc_hd__decap_3
X_4066_ _4062_/X _4065_/X _4425_/A VGND VGND VPWR VPWR _4082_/A sky130_fd_sc_hd__o21a_2
XTAP_TAPCELL_ROW_104_1505 VGND VPWR sky130_fd_sc_hd__tapvpwrvgnd_1
XFILLER_51_231 VGND VGND VPWR VPWR sky130_fd_sc_hd__decap_3
XTAP_TAPCELL_ROW_19_481 VGND VPWR sky130_fd_sc_hd__tapvpwrvgnd_1
XFILLER_51_253 VGND VGND VPWR VPWR sky130_fd_sc_hd__decap_3
XFILLER_11_128 VGND VGND VPWR VPWR sky130_fd_sc_hd__decap_3
X_4968_ _4968_/A _4967_/B VGND VGND VPWR VPWR _4968_/Y sky130_fd_sc_hd__nor2b_2
XFILLER_22_24 VGND VGND VPWR VPWR sky130_fd_sc_hd__decap_3
X_6707_ _7198_/CLK _6707_/D VGND VGND VPWR VPWR _6707_/Q sky130_fd_sc_hd__dfxtp_2
X_4899_ _4836_/S _6998_/D _5656_/B _4898_/X VGND VGND VPWR VPWR _4899_/X sky130_fd_sc_hd__o22a_2
X_3919_ _3629_/A _3918_/X _5104_/A VGND VGND VPWR VPWR _3919_/X sky130_fd_sc_hd__a21o_2
XFILLER_22_35 VGND VGND VPWR VPWR sky130_fd_sc_hd__decap_3
X_6638_ _6638_/A VGND VGND VPWR VPWR _6638_/Y sky130_fd_sc_hd__inv_2
XFILLER_22_68 VGND VGND VPWR VPWR sky130_fd_sc_hd__decap_3
XFILLER_105_211 VGND VGND VPWR VPWR sky130_fd_sc_hd__decap_3
XFILLER_3_305 VGND VGND VPWR VPWR sky130_fd_sc_hd__decap_3
X_6569_ _6638_/A VGND VGND VPWR VPWR _6569_/Y sky130_fd_sc_hd__inv_2
XTAP_TAPCELL_ROW_115_1634 VGND VPWR sky130_fd_sc_hd__tapvpwrvgnd_1
XFILLER_79_607 VGND VGND VPWR VPWR sky130_fd_sc_hd__decap_3
XFILLER_105_266 VGND VGND VPWR VPWR sky130_fd_sc_hd__decap_3
XFILLER_79_629 VGND VGND VPWR VPWR sky130_fd_sc_hd__decap_3
Xoutput470 _5662_/A VGND VGND VPWR VPWR alu_result_out[14] sky130_fd_sc_hd__clkdlybuf4s25_1
XFILLER_59_320 VGND VGND VPWR VPWR sky130_fd_sc_hd__decap_3
Xoutput492 _3746_/C VGND VGND VPWR VPWR alu_result_out[5] sky130_fd_sc_hd__clkdlybuf4s25_1
Xoutput481 _5657_/A VGND VGND VPWR VPWR alu_result_out[24] sky130_fd_sc_hd__clkdlybuf4s25_1
XFILLER_47_21 VGND VGND VPWR VPWR sky130_fd_sc_hd__decap_3
XFILLER_86_150 VGND VGND VPWR VPWR sky130_fd_sc_hd__decap_3
XFILLER_87_673 VGND VGND VPWR VPWR sky130_fd_sc_hd__fill_1
XFILLER_93_109 VGND VGND VPWR VPWR sky130_fd_sc_hd__decap_3
XFILLER_19_228 VGND VGND VPWR VPWR sky130_fd_sc_hd__decap_3
XFILLER_47_54 VGND VGND VPWR VPWR sky130_fd_sc_hd__fill_2
XFILLER_59_386 VGND VGND VPWR VPWR sky130_fd_sc_hd__decap_3
XFILLER_74_312 VGND VGND VPWR VPWR sky130_fd_sc_hd__decap_3
XFILLER_47_548 VGND VGND VPWR VPWR sky130_fd_sc_hd__fill_1
XFILLER_47_65 VGND VGND VPWR VPWR sky130_fd_sc_hd__decap_3
XFILLER_74_356 VGND VGND VPWR VPWR sky130_fd_sc_hd__decap_3
XFILLER_103_60 VGND VGND VPWR VPWR sky130_fd_sc_hd__decap_3
XFILLER_62_529 VGND VGND VPWR VPWR sky130_fd_sc_hd__decap_3
XFILLER_15_423 VGND VGND VPWR VPWR sky130_fd_sc_hd__decap_3
XFILLER_30_404 VGND VGND VPWR VPWR sky130_fd_sc_hd__fill_1
XFILLER_42_253 VGND VGND VPWR VPWR sky130_fd_sc_hd__decap_3
XFILLER_70_551 VGND VGND VPWR VPWR sky130_fd_sc_hd__decap_3
XPHY_EDGE_ROW_69_Right_69 VGND VGND VPWR VPWR sky130_fd_sc_hd__decap_3
XFILLER_30_415 VGND VGND VPWR VPWR sky130_fd_sc_hd__decap_3
XFILLER_42_275 VGND VGND VPWR VPWR sky130_fd_sc_hd__decap_3
XFILLER_63_86 VGND VGND VPWR VPWR sky130_fd_sc_hd__decap_3
XFILLER_70_595 VGND VGND VPWR VPWR sky130_fd_sc_hd__decap_3
XFILLER_8_26 VGND VGND VPWR VPWR sky130_fd_sc_hd__fill_2
XFILLER_10_150 VGND VGND VPWR VPWR sky130_fd_sc_hd__decap_3
XFILLER_10_172 VGND VGND VPWR VPWR sky130_fd_sc_hd__decap_3
XFILLER_109_561 VGND VGND VPWR VPWR sky130_fd_sc_hd__decap_3
XFILLER_109_594 VGND VGND VPWR VPWR sky130_fd_sc_hd__decap_3
XPHY_EDGE_ROW_78_Right_78 VGND VGND VPWR VPWR sky130_fd_sc_hd__decap_3
XFILLER_97_426 VGND VGND VPWR VPWR sky130_fd_sc_hd__decap_3
XTAP_TAPCELL_ROW_90_1328 VGND VPWR sky130_fd_sc_hd__tapvpwrvgnd_1
XFILLER_111_225 VGND VGND VPWR VPWR sky130_fd_sc_hd__decap_3
XFILLER_2_360 VGND VGND VPWR VPWR sky130_fd_sc_hd__fill_1
XFILLER_33_6 VGND VGND VPWR VPWR sky130_fd_sc_hd__fill_1
XFILLER_69_128 VGND VGND VPWR VPWR sky130_fd_sc_hd__decap_3
XFILLER_88_94 VGND VGND VPWR VPWR sky130_fd_sc_hd__decap_3
XFILLER_111_247 VGND VGND VPWR VPWR sky130_fd_sc_hd__decap_3
XFILLER_78_640 VGND VGND VPWR VPWR sky130_fd_sc_hd__decap_3
XFILLER_84_109 VGND VGND VPWR VPWR sky130_fd_sc_hd__decap_3
Xload_slew569 _3522_/Y VGND VGND VPWR VPWR _4814_/A sky130_fd_sc_hd__clkbuf_4
XFILLER_38_515 VGND VGND VPWR VPWR sky130_fd_sc_hd__fill_1
XFILLER_65_301 VGND VGND VPWR VPWR sky130_fd_sc_hd__decap_3
XFILLER_77_172 VGND VGND VPWR VPWR sky130_fd_sc_hd__decap_3
XFILLER_77_183 VGND VGND VPWR VPWR sky130_fd_sc_hd__decap_3
XFILLER_65_334 VGND VGND VPWR VPWR sky130_fd_sc_hd__fill_2
XFILLER_18_250 VGND VGND VPWR VPWR sky130_fd_sc_hd__fill_2
XFILLER_65_367 VGND VGND VPWR VPWR sky130_fd_sc_hd__decap_3
XFILLER_80_304 VGND VGND VPWR VPWR sky130_fd_sc_hd__decap_3
XFILLER_80_315 VGND VGND VPWR VPWR sky130_fd_sc_hd__fill_2
XFILLER_92_153 VGND VGND VPWR VPWR sky130_fd_sc_hd__fill_2
XFILLER_92_164 VGND VGND VPWR VPWR sky130_fd_sc_hd__decap_3
XFILLER_18_283 VGND VGND VPWR VPWR sky130_fd_sc_hd__decap_3
XFILLER_80_326 VGND VGND VPWR VPWR sky130_fd_sc_hd__fill_2
XFILLER_80_359 VGND VGND VPWR VPWR sky130_fd_sc_hd__decap_3
XPHY_EDGE_ROW_87_Right_87 VGND VGND VPWR VPWR sky130_fd_sc_hd__decap_3
XFILLER_33_231 VGND VGND VPWR VPWR sky130_fd_sc_hd__decap_3
XTAP_TAPCELL_ROW_16_440 VGND VPWR sky130_fd_sc_hd__tapvpwrvgnd_1
XFILLER_33_275 VGND VGND VPWR VPWR sky130_fd_sc_hd__decap_3
X_4822_ _4836_/S _7002_/D _5663_/B _4821_/X VGND VGND VPWR VPWR _4822_/X sky130_fd_sc_hd__o22a_2
XTAP_TAPCELL_ROW_44_782 VGND VPWR sky130_fd_sc_hd__tapvpwrvgnd_1
X_4753_ _4753_/A0 _4752_/X _4793_/S VGND VGND VPWR VPWR _7276_/D sky130_fd_sc_hd__mux2_2
X_3704_ _6712_/Q _3826_/A2 _3827_/B1 _6890_/Q _3703_/X VGND VGND VPWR VPWR _3704_/X
+ sky130_fd_sc_hd__a221o_2
X_6423_ _6617_/A VGND VGND VPWR VPWR _6423_/Y sky130_fd_sc_hd__inv_2
X_4684_ _6996_/Q _4668_/X _4943_/A _4683_/X VGND VGND VPWR VPWR _4684_/X sky130_fd_sc_hd__a31o_2
X_3635_ _3635_/A _3635_/B _3547_/A VGND VGND VPWR VPWR _3635_/X sky130_fd_sc_hd__or3b_2
XPHY_EDGE_ROW_96_Right_96 VGND VGND VPWR VPWR sky130_fd_sc_hd__decap_3
XFILLER_108_27 VGND VGND VPWR VPWR sky130_fd_sc_hd__fill_1
XFILLER_108_38 VGND VGND VPWR VPWR sky130_fd_sc_hd__decap_3
XFILLER_115_531 VGND VGND VPWR VPWR sky130_fd_sc_hd__fill_1
X_6354_ _6388_/A VGND VGND VPWR VPWR _6354_/Y sky130_fd_sc_hd__inv_2
X_3566_ _7189_/Q _3977_/S _4338_/B1 _7381_/Q VGND VGND VPWR VPWR _3566_/X sky130_fd_sc_hd__a22o_2
X_6285_ _6287_/A VGND VGND VPWR VPWR _6285_/Y sky130_fd_sc_hd__inv_2
X_3497_ _7151_/Q _3409_/X _3493_/X _3496_/X VGND VGND VPWR VPWR _3497_/X sky130_fd_sc_hd__a211o_2
XFILLER_102_214 VGND VGND VPWR VPWR sky130_fd_sc_hd__decap_3
X_5236_ _5236_/A0 _4752_/X _5245_/S VGND VGND VPWR VPWR _7212_/D sky130_fd_sc_hd__mux2_2
XFILLER_102_247 VGND VGND VPWR VPWR sky130_fd_sc_hd__decap_3
XFILLER_69_640 VGND VGND VPWR VPWR sky130_fd_sc_hd__decap_3
XFILLER_69_651 VGND VGND VPWR VPWR sky130_fd_sc_hd__decap_3
XFILLER_69_662 VGND VGND VPWR VPWR sky130_fd_sc_hd__decap_3
XTAP_TAPCELL_ROW_110_1575 VGND VPWR sky130_fd_sc_hd__tapvpwrvgnd_1
XFILLER_29_537 VGND VGND VPWR VPWR sky130_fd_sc_hd__decap_3
XFILLER_56_301 VGND VGND VPWR VPWR sky130_fd_sc_hd__decap_3
XFILLER_68_150 VGND VGND VPWR VPWR sky130_fd_sc_hd__fill_1
XFILLER_69_673 VGND VGND VPWR VPWR sky130_fd_sc_hd__decap_3
XFILLER_69_684 VGND VGND VPWR VPWR sky130_fd_sc_hd__fill_2
X_5167_ _5167_/A _5190_/B VGND VGND VPWR VPWR _7244_/D sky130_fd_sc_hd__and2_2
XPHY_EDGE_ROW_3_Left_120 VGND VGND VPWR VPWR sky130_fd_sc_hd__decap_3
XFILLER_110_280 VGND VGND VPWR VPWR sky130_fd_sc_hd__fill_2
XFILLER_29_559 VGND VGND VPWR VPWR sky130_fd_sc_hd__fill_1
XFILLER_56_345 VGND VGND VPWR VPWR sky130_fd_sc_hd__decap_3
XFILLER_68_194 VGND VGND VPWR VPWR sky130_fd_sc_hd__fill_2
XFILLER_96_492 VGND VGND VPWR VPWR sky130_fd_sc_hd__decap_3
X_5098_ _5098_/A _5098_/B VGND VGND VPWR VPWR _6985_/D sky130_fd_sc_hd__nor2_2
X_4118_ _7021_/Q _4418_/A2 _4394_/B _7364_/Q VGND VGND VPWR VPWR _4118_/X sky130_fd_sc_hd__a22o_2
XFILLER_16_209 VGND VGND VPWR VPWR sky130_fd_sc_hd__decap_3
X_4049_ _7213_/Q _3943_/S _4793_/S _7309_/Q _4048_/X VGND VGND VPWR VPWR _4049_/X
+ sky130_fd_sc_hd__a221o_2
XFILLER_17_57 VGND VGND VPWR VPWR sky130_fd_sc_hd__decap_3
XFILLER_17_79 VGND VGND VPWR VPWR sky130_fd_sc_hd__decap_3
XFILLER_71_337 VGND VGND VPWR VPWR sky130_fd_sc_hd__fill_1
XFILLER_24_253 VGND VGND VPWR VPWR sky130_fd_sc_hd__decap_3
XTAP_TAPCELL_ROW_65_1032 VGND VPWR sky130_fd_sc_hd__tapvpwrvgnd_1
XFILLER_24_275 VGND VGND VPWR VPWR sky130_fd_sc_hd__decap_3
XFILLER_33_45 VGND VGND VPWR VPWR sky130_fd_sc_hd__decap_3
XFILLER_8_419 VGND VGND VPWR VPWR sky130_fd_sc_hd__fill_1
XPHY_EDGE_ROW_49_Left_166 VGND VGND VPWR VPWR sky130_fd_sc_hd__decap_3
XFILLER_106_520 VGND VGND VPWR VPWR sky130_fd_sc_hd__decap_3
XFILLER_3_135 VGND VGND VPWR VPWR sky130_fd_sc_hd__decap_3
XTAP_TAPCELL_ROW_76_1161 VGND VPWR sky130_fd_sc_hd__tapvpwrvgnd_1
XFILLER_3_179 VGND VGND VPWR VPWR sky130_fd_sc_hd__fill_2
XFILLER_79_426 VGND VGND VPWR VPWR sky130_fd_sc_hd__decap_3
XFILLER_58_64 VGND VGND VPWR VPWR sky130_fd_sc_hd__decap_3
XFILLER_94_418 VGND VGND VPWR VPWR sky130_fd_sc_hd__fill_2
XFILLER_59_150 VGND VGND VPWR VPWR sky130_fd_sc_hd__decap_3
XFILLER_59_172 VGND VGND VPWR VPWR sky130_fd_sc_hd__decap_3
XFILLER_87_470 VGND VGND VPWR VPWR sky130_fd_sc_hd__decap_3
XPHY_EDGE_ROW_58_Left_175 VGND VGND VPWR VPWR sky130_fd_sc_hd__decap_3
XFILLER_47_323 VGND VGND VPWR VPWR sky130_fd_sc_hd__decap_3
XFILLER_59_194 VGND VGND VPWR VPWR sky130_fd_sc_hd__decap_3
XFILLER_75_632 VGND VGND VPWR VPWR sky130_fd_sc_hd__decap_3
XFILLER_47_389 VGND VGND VPWR VPWR sky130_fd_sc_hd__decap_3
XFILLER_74_153 VGND VGND VPWR VPWR sky130_fd_sc_hd__decap_3
XFILLER_75_687 VGND VGND VPWR VPWR sky130_fd_sc_hd__decap_3
XFILLER_62_326 VGND VGND VPWR VPWR sky130_fd_sc_hd__decap_3
XFILLER_74_186 VGND VGND VPWR VPWR sky130_fd_sc_hd__decap_3
XFILLER_74_197 VGND VGND VPWR VPWR sky130_fd_sc_hd__decap_3
XFILLER_15_231 VGND VGND VPWR VPWR sky130_fd_sc_hd__decap_3
XFILLER_62_359 VGND VGND VPWR VPWR sky130_fd_sc_hd__fill_1
XTAP_TAPCELL_ROW_87_1290 VGND VPWR sky130_fd_sc_hd__tapvpwrvgnd_1
XFILLER_15_264 VGND VGND VPWR VPWR sky130_fd_sc_hd__decap_3
XFILLER_30_234 VGND VGND VPWR VPWR sky130_fd_sc_hd__decap_3
XFILLER_90_62 VGND VGND VPWR VPWR sky130_fd_sc_hd__decap_3
XTAP_TAPCELL_ROW_41_741 VGND VPWR sky130_fd_sc_hd__tapvpwrvgnd_1
XTAP_TAPCELL_ROW_13_410 VGND VPWR sky130_fd_sc_hd__tapvpwrvgnd_1
XPHY_EDGE_ROW_67_Left_184 VGND VGND VPWR VPWR sky130_fd_sc_hd__decap_3
XFILLER_30_256 VGND VGND VPWR VPWR sky130_fd_sc_hd__decap_3
XFILLER_30_289 VGND VGND VPWR VPWR sky130_fd_sc_hd__decap_3
XFILLER_7_430 VGND VGND VPWR VPWR sky130_fd_sc_hd__decap_3
XFILLER_7_452 VGND VGND VPWR VPWR sky130_fd_sc_hd__decap_3
XFILLER_109_391 VGND VGND VPWR VPWR sky130_fd_sc_hd__fill_1
X_3420_ _3420_/A _5642_/B VGND VGND VPWR VPWR _3442_/B sky130_fd_sc_hd__or2_2
X_3351_ _5130_/A _3350_/Y _3340_/B VGND VGND VPWR VPWR _5642_/B sky130_fd_sc_hd__o21a_2
XFILLER_99_93 VGND VGND VPWR VPWR sky130_fd_sc_hd__decap_3
XFILLER_31_3 VGND VGND VPWR VPWR sky130_fd_sc_hd__decap_3
XFILLER_97_223 VGND VGND VPWR VPWR sky130_fd_sc_hd__fill_1
XFILLER_112_567 VGND VGND VPWR VPWR sky130_fd_sc_hd__decap_3
XFILLER_112_578 VGND VGND VPWR VPWR sky130_fd_sc_hd__decap_3
XFILLER_97_267 VGND VGND VPWR VPWR sky130_fd_sc_hd__fill_1
XPHY_EDGE_ROW_76_Left_193 VGND VGND VPWR VPWR sky130_fd_sc_hd__decap_3
XFILLER_112_589 VGND VGND VPWR VPWR sky130_fd_sc_hd__decap_3
XFILLER_78_470 VGND VGND VPWR VPWR sky130_fd_sc_hd__decap_3
XFILLER_85_429 VGND VGND VPWR VPWR sky130_fd_sc_hd__decap_3
Xhold1108 _7323_/Q VGND VGND VPWR VPWR _4513_/A0 sky130_fd_sc_hd__dlygate4sd3_1
Xhold1119 _7040_/Q VGND VGND VPWR VPWR _5577_/A0 sky130_fd_sc_hd__dlygate4sd3_1
X_5021_ _3604_/B _4372_/A _5018_/A _5101_/A VGND VGND VPWR VPWR _5021_/X sky130_fd_sc_hd__o2bb2a_2
XFILLER_66_632 VGND VGND VPWR VPWR sky130_fd_sc_hd__decap_3
XTAP_TAPCELL_ROW_49_841 VGND VPWR sky130_fd_sc_hd__tapvpwrvgnd_1
XFILLER_38_356 VGND VGND VPWR VPWR sky130_fd_sc_hd__fill_2
XFILLER_65_142 VGND VGND VPWR VPWR sky130_fd_sc_hd__fill_1
XFILLER_66_665 VGND VGND VPWR VPWR sky130_fd_sc_hd__decap_3
XFILLER_93_462 VGND VGND VPWR VPWR sky130_fd_sc_hd__decap_3
XFILLER_53_326 VGND VGND VPWR VPWR sky130_fd_sc_hd__decap_3
XFILLER_53_337 VGND VGND VPWR VPWR sky130_fd_sc_hd__decap_3
XFILLER_65_175 VGND VGND VPWR VPWR sky130_fd_sc_hd__decap_3
XFILLER_80_134 VGND VGND VPWR VPWR sky130_fd_sc_hd__decap_3
XFILLER_81_635 VGND VGND VPWR VPWR sky130_fd_sc_hd__decap_3
XFILLER_81_646 VGND VGND VPWR VPWR sky130_fd_sc_hd__decap_3
XFILLER_81_657 VGND VGND VPWR VPWR sky130_fd_sc_hd__decap_3
X_6972_ _6972_/CLK _6972_/D VGND VGND VPWR VPWR _6972_/Q sky130_fd_sc_hd__dfxtp_2
XFILLER_34_551 VGND VGND VPWR VPWR sky130_fd_sc_hd__decap_3
XFILLER_81_679 VGND VGND VPWR VPWR sky130_fd_sc_hd__decap_3
XFILLER_110_39 VGND VGND VPWR VPWR sky130_fd_sc_hd__decap_3
XFILLER_61_370 VGND VGND VPWR VPWR sky130_fd_sc_hd__decap_3
XFILLER_61_381 VGND VGND VPWR VPWR sky130_fd_sc_hd__decap_3
XFILLER_21_234 VGND VGND VPWR VPWR sky130_fd_sc_hd__decap_3
X_4805_ _4997_/A1 _7003_/D _4804_/X VGND VGND VPWR VPWR _4805_/X sky130_fd_sc_hd__a21bo_2
XFILLER_21_267 VGND VGND VPWR VPWR sky130_fd_sc_hd__decap_3
X_4667_ _6998_/Q _5611_/B VGND VGND VPWR VPWR _4896_/A sky130_fd_sc_hd__xnor2_2
X_7386_ _7390_/CLK _7386_/D _6666_/Y VGND VGND VPWR VPWR _7386_/Q sky130_fd_sc_hd__dfrtp_2
Xhold920 _6707_/Q VGND VGND VPWR VPWR hold920/X sky130_fd_sc_hd__dlygate4sd3_1
Xhold931 _6704_/Q VGND VGND VPWR VPWR hold931/X sky130_fd_sc_hd__dlygate4sd3_1
X_6406_ _6532_/A VGND VGND VPWR VPWR _6406_/Y sky130_fd_sc_hd__inv_2
X_3618_ _5118_/C _4938_/A _3618_/C VGND VGND VPWR VPWR _3618_/X sky130_fd_sc_hd__and3_2
XFILLER_115_350 VGND VGND VPWR VPWR sky130_fd_sc_hd__decap_3
Xhold942 _5678_/X VGND VGND VPWR VPWR _6689_/D sky130_fd_sc_hd__dlygate4sd3_1
Xhold964 _7029_/Q VGND VGND VPWR VPWR hold964/X sky130_fd_sc_hd__dlygate4sd3_1
Xhold953 _5682_/X VGND VGND VPWR VPWR _6691_/D sky130_fd_sc_hd__dlygate4sd3_1
X_6337_ _6347_/A VGND VGND VPWR VPWR _6337_/Y sky130_fd_sc_hd__inv_2
XFILLER_0_116 VGND VGND VPWR VPWR sky130_fd_sc_hd__fill_2
XFILLER_103_523 VGND VGND VPWR VPWR sky130_fd_sc_hd__decap_3
XFILLER_88_223 VGND VGND VPWR VPWR sky130_fd_sc_hd__decap_3
Xhold997 _7017_/Q VGND VGND VPWR VPWR _5621_/A sky130_fd_sc_hd__dlygate4sd3_1
Xhold986 _7019_/Q VGND VGND VPWR VPWR _5617_/A sky130_fd_sc_hd__dlygate4sd3_1
Xhold975 _7211_/Q VGND VGND VPWR VPWR hold975/X sky130_fd_sc_hd__dlygate4sd3_1
XFILLER_88_256 VGND VGND VPWR VPWR sky130_fd_sc_hd__decap_3
XFILLER_95_18 VGND VGND VPWR VPWR sky130_fd_sc_hd__decap_3
X_6268_ _6366_/A VGND VGND VPWR VPWR _6268_/Y sky130_fd_sc_hd__inv_2
XFILLER_28_12 VGND VGND VPWR VPWR sky130_fd_sc_hd__decap_3
XFILLER_29_301 VGND VGND VPWR VPWR sky130_fd_sc_hd__decap_3
XFILLER_76_418 VGND VGND VPWR VPWR sky130_fd_sc_hd__fill_2
X_5219_ _5219_/A _5225_/B VGND VGND VPWR VPWR _7219_/D sky130_fd_sc_hd__and2_2
XFILLER_28_56 VGND VGND VPWR VPWR sky130_fd_sc_hd__decap_3
XFILLER_28_78 VGND VGND VPWR VPWR sky130_fd_sc_hd__decap_3
XFILLER_56_153 VGND VGND VPWR VPWR sky130_fd_sc_hd__decap_3
XFILLER_84_462 VGND VGND VPWR VPWR sky130_fd_sc_hd__decap_3
XFILLER_29_389 VGND VGND VPWR VPWR sky130_fd_sc_hd__decap_3
XFILLER_44_315 VGND VGND VPWR VPWR sky130_fd_sc_hd__decap_3
XFILLER_44_348 VGND VGND VPWR VPWR sky130_fd_sc_hd__decap_3
XFILLER_56_186 VGND VGND VPWR VPWR sky130_fd_sc_hd__decap_3
XFILLER_56_197 VGND VGND VPWR VPWR sky130_fd_sc_hd__decap_3
XFILLER_71_123 VGND VGND VPWR VPWR sky130_fd_sc_hd__decap_3
XFILLER_84_495 VGND VGND VPWR VPWR sky130_fd_sc_hd__decap_3
XFILLER_44_22 VGND VGND VPWR VPWR sky130_fd_sc_hd__decap_3
XFILLER_12_212 VGND VGND VPWR VPWR sky130_fd_sc_hd__decap_3
XFILLER_44_55 VGND VGND VPWR VPWR sky130_fd_sc_hd__decap_3
XTAP_TAPCELL_ROW_27_579 VGND VPWR sky130_fd_sc_hd__tapvpwrvgnd_1
XFILLER_12_234 VGND VGND VPWR VPWR sky130_fd_sc_hd__decap_3
XFILLER_40_554 VGND VGND VPWR VPWR sky130_fd_sc_hd__fill_1
XFILLER_100_50 VGND VGND VPWR VPWR sky130_fd_sc_hd__decap_3
XFILLER_12_256 VGND VGND VPWR VPWR sky130_fd_sc_hd__decap_3
XFILLER_60_21 VGND VGND VPWR VPWR sky130_fd_sc_hd__decap_3
XFILLER_100_94 VGND VGND VPWR VPWR sky130_fd_sc_hd__fill_1
XFILLER_12_289 VGND VGND VPWR VPWR sky130_fd_sc_hd__decap_3
XFILLER_8_238 VGND VGND VPWR VPWR sky130_fd_sc_hd__decap_3
XFILLER_60_76 VGND VGND VPWR VPWR sky130_fd_sc_hd__decap_3
XFILLER_4_411 VGND VGND VPWR VPWR sky130_fd_sc_hd__decap_3
XFILLER_5_27 VGND VGND VPWR VPWR sky130_fd_sc_hd__decap_3
XFILLER_69_30 VGND VGND VPWR VPWR sky130_fd_sc_hd__decap_3
XFILLER_106_383 VGND VGND VPWR VPWR sky130_fd_sc_hd__decap_3
XFILLER_69_52 VGND VGND VPWR VPWR sky130_fd_sc_hd__decap_3
XFILLER_69_63 VGND VGND VPWR VPWR sky130_fd_sc_hd__decap_3
XFILLER_69_96 VGND VGND VPWR VPWR sky130_fd_sc_hd__decap_3
XFILLER_79_245 VGND VGND VPWR VPWR sky130_fd_sc_hd__decap_3
XFILLER_79_278 VGND VGND VPWR VPWR sky130_fd_sc_hd__fill_2
XFILLER_94_215 VGND VGND VPWR VPWR sky130_fd_sc_hd__decap_3
XFILLER_85_51 VGND VGND VPWR VPWR sky130_fd_sc_hd__decap_3
XFILLER_94_259 VGND VGND VPWR VPWR sky130_fd_sc_hd__decap_3
XFILLER_47_164 VGND VGND VPWR VPWR sky130_fd_sc_hd__decap_3
XFILLER_75_473 VGND VGND VPWR VPWR sky130_fd_sc_hd__decap_3
XFILLER_85_84 VGND VGND VPWR VPWR sky130_fd_sc_hd__decap_3
XTAP_TAPCELL_ROW_46_800 VGND VPWR sky130_fd_sc_hd__tapvpwrvgnd_1
XFILLER_35_337 VGND VGND VPWR VPWR sky130_fd_sc_hd__decap_3
XFILLER_47_175 VGND VGND VPWR VPWR sky130_fd_sc_hd__decap_3
XFILLER_62_134 VGND VGND VPWR VPWR sky130_fd_sc_hd__decap_3
XFILLER_62_145 VGND VGND VPWR VPWR sky130_fd_sc_hd__decap_3
XFILLER_63_679 VGND VGND VPWR VPWR sky130_fd_sc_hd__fill_2
XFILLER_90_443 VGND VGND VPWR VPWR sky130_fd_sc_hd__decap_3
XFILLER_62_178 VGND VGND VPWR VPWR sky130_fd_sc_hd__decap_3
XFILLER_90_498 VGND VGND VPWR VPWR sky130_fd_sc_hd__decap_3
X_5570_ hold988/X _4975_/A _4929_/Y VGND VGND VPWR VPWR _7047_/D sky130_fd_sc_hd__o21a_2
XFILLER_116_103 VGND VGND VPWR VPWR sky130_fd_sc_hd__fill_1
XFILLER_116_136 VGND VGND VPWR VPWR sky130_fd_sc_hd__decap_3
XFILLER_7_271 VGND VGND VPWR VPWR sky130_fd_sc_hd__decap_3
XFILLER_7_293 VGND VGND VPWR VPWR sky130_fd_sc_hd__decap_3
X_7240_ _7365_/CLK _7240_/D _6520_/Y VGND VGND VPWR VPWR _7240_/Q sky130_fd_sc_hd__dfrtp_2
X_4452_ _4452_/A _4765_/B VGND VGND VPWR VPWR _4453_/A sky130_fd_sc_hd__or2_2
XFILLER_116_169 VGND VGND VPWR VPWR sky130_fd_sc_hd__decap_3
X_3403_ _5129_/B _4467_/B VGND VGND VPWR VPWR _5634_/B sky130_fd_sc_hd__or2_4
XPHY_EDGE_ROW_84_Left_201 VGND VGND VPWR VPWR sky130_fd_sc_hd__decap_3
X_7171_ _7363_/CLK _7171_/D _6451_/Y VGND VGND VPWR VPWR _7171_/Q sky130_fd_sc_hd__dfrtp_2
X_4383_ _4920_/A _4937_/A _4383_/C VGND VGND VPWR VPWR _4384_/C sky130_fd_sc_hd__and3_2
XFILLER_98_510 VGND VGND VPWR VPWR sky130_fd_sc_hd__decap_3
XFILLER_112_320 VGND VGND VPWR VPWR sky130_fd_sc_hd__decap_3
XFILLER_112_353 VGND VGND VPWR VPWR sky130_fd_sc_hd__decap_3
X_3334_ _3330_/Y _3528_/A _3341_/A VGND VGND VPWR VPWR _3334_/Y sky130_fd_sc_hd__o21ai_2
XFILLER_98_554 VGND VGND VPWR VPWR sky130_fd_sc_hd__decap_3
XFILLER_100_515 VGND VGND VPWR VPWR sky130_fd_sc_hd__decap_3
XFILLER_105_28 VGND VGND VPWR VPWR sky130_fd_sc_hd__decap_3
XFILLER_112_386 VGND VGND VPWR VPWR sky130_fd_sc_hd__decap_3
XFILLER_58_418 VGND VGND VPWR VPWR sky130_fd_sc_hd__fill_2
XFILLER_85_215 VGND VGND VPWR VPWR sky130_fd_sc_hd__decap_3
XFILLER_98_587 VGND VGND VPWR VPWR sky130_fd_sc_hd__fill_1
XFILLER_85_237 VGND VGND VPWR VPWR sky130_fd_sc_hd__decap_3
X_5004_ _5004_/A _5004_/B VGND VGND VPWR VPWR _5004_/X sky130_fd_sc_hd__or2_2
XFILLER_38_153 VGND VGND VPWR VPWR sky130_fd_sc_hd__decap_3
XFILLER_39_665 VGND VGND VPWR VPWR sky130_fd_sc_hd__decap_3
XFILLER_66_451 VGND VGND VPWR VPWR sky130_fd_sc_hd__decap_3
XFILLER_26_315 VGND VGND VPWR VPWR sky130_fd_sc_hd__decap_3
XFILLER_38_186 VGND VGND VPWR VPWR sky130_fd_sc_hd__decap_3
XFILLER_38_197 VGND VGND VPWR VPWR sky130_fd_sc_hd__decap_3
XFILLER_66_495 VGND VGND VPWR VPWR sky130_fd_sc_hd__decap_3
XFILLER_81_443 VGND VGND VPWR VPWR sky130_fd_sc_hd__decap_3
X_6955_ _6967_/CLK _6955_/D VGND VGND VPWR VPWR _6955_/Q sky130_fd_sc_hd__dfxtp_2
XPHY_EDGE_ROW_93_Left_210 VGND VGND VPWR VPWR sky130_fd_sc_hd__decap_3
XFILLER_53_167 VGND VGND VPWR VPWR sky130_fd_sc_hd__fill_1
XFILLER_53_178 VGND VGND VPWR VPWR sky130_fd_sc_hd__fill_1
XFILLER_53_189 VGND VGND VPWR VPWR sky130_fd_sc_hd__decap_3
XFILLER_81_476 VGND VGND VPWR VPWR sky130_fd_sc_hd__decap_3
XFILLER_14_14 VGND VGND VPWR VPWR sky130_fd_sc_hd__decap_3
X_6886_ _7406_/CLK _6886_/D VGND VGND VPWR VPWR _6886_/Q sky130_fd_sc_hd__dfxtp_2
XTAP_TAPCELL_ROW_24_538 VGND VPWR sky130_fd_sc_hd__tapvpwrvgnd_1
XFILLER_108_604 VGND VGND VPWR VPWR sky130_fd_sc_hd__decap_3
XFILLER_5_208 VGND VGND VPWR VPWR sky130_fd_sc_hd__decap_3
XFILLER_108_637 VGND VGND VPWR VPWR sky130_fd_sc_hd__decap_3
X_5699_ _7355_/Q hold932/X _5708_/S VGND VGND VPWR VPWR _6699_/D sky130_fd_sc_hd__mux2_2
XFILLER_100_6 VGND VGND VPWR VPWR sky130_fd_sc_hd__decap_3
XFILLER_116_670 VGND VGND VPWR VPWR sky130_fd_sc_hd__fill_2
X_7369_ _7371_/CLK _7369_/D _6649_/Y VGND VGND VPWR VPWR _7369_/Q sky130_fd_sc_hd__dfrtp_2
Xhold750 _6936_/Q VGND VGND VPWR VPWR _6936_/D sky130_fd_sc_hd__dlygate4sd3_1
Xhold761 _6723_/Q VGND VGND VPWR VPWR _6723_/D sky130_fd_sc_hd__dlygate4sd3_1
Xhold772 _6749_/Q VGND VGND VPWR VPWR _6749_/D sky130_fd_sc_hd__dlygate4sd3_1
XTAP_TAPCELL_ROW_73_1131 VGND VPWR sky130_fd_sc_hd__tapvpwrvgnd_1
XFILLER_103_320 VGND VGND VPWR VPWR sky130_fd_sc_hd__decap_3
XFILLER_39_33 VGND VGND VPWR VPWR sky130_fd_sc_hd__decap_3
XFILLER_89_543 VGND VGND VPWR VPWR sky130_fd_sc_hd__decap_3
Xhold783 _6959_/Q VGND VGND VPWR VPWR _6959_/D sky130_fd_sc_hd__dlygate4sd3_1
Xhold794 _6752_/Q VGND VGND VPWR VPWR _6752_/D sky130_fd_sc_hd__dlygate4sd3_1
XFILLER_103_364 VGND VGND VPWR VPWR sky130_fd_sc_hd__decap_3
XFILLER_39_55 VGND VGND VPWR VPWR sky130_fd_sc_hd__fill_1
XFILLER_49_407 VGND VGND VPWR VPWR sky130_fd_sc_hd__decap_3
XFILLER_89_587 VGND VGND VPWR VPWR sky130_fd_sc_hd__decap_3
XFILLER_76_226 VGND VGND VPWR VPWR sky130_fd_sc_hd__decap_3
XFILLER_91_207 VGND VGND VPWR VPWR sky130_fd_sc_hd__decap_3
XFILLER_17_326 VGND VGND VPWR VPWR sky130_fd_sc_hd__decap_3
XFILLER_17_337 VGND VGND VPWR VPWR sky130_fd_sc_hd__decap_3
XFILLER_29_164 VGND VGND VPWR VPWR sky130_fd_sc_hd__decap_3
XFILLER_29_175 VGND VGND VPWR VPWR sky130_fd_sc_hd__decap_3
XFILLER_72_410 VGND VGND VPWR VPWR sky130_fd_sc_hd__decap_3
XFILLER_72_421 VGND VGND VPWR VPWR sky130_fd_sc_hd__decap_3
XTAP_TAPCELL_ROW_4_296 VGND VPWR sky130_fd_sc_hd__tapvpwrvgnd_1
XFILLER_44_134 VGND VGND VPWR VPWR sky130_fd_sc_hd__decap_3
XFILLER_72_454 VGND VGND VPWR VPWR sky130_fd_sc_hd__decap_3
XFILLER_25_370 VGND VGND VPWR VPWR sky130_fd_sc_hd__decap_3
XFILLER_32_307 VGND VGND VPWR VPWR sky130_fd_sc_hd__fill_1
XFILLER_32_329 VGND VGND VPWR VPWR sky130_fd_sc_hd__fill_2
XFILLER_44_178 VGND VGND VPWR VPWR sky130_fd_sc_hd__decap_3
XTAP_TAPCELL_ROW_84_1260 VGND VPWR sky130_fd_sc_hd__tapvpwrvgnd_1
XPHY_EDGE_ROW_105_Right_105 VGND VGND VPWR VPWR sky130_fd_sc_hd__decap_3
XFILLER_111_60 VGND VGND VPWR VPWR sky130_fd_sc_hd__decap_3
XFILLER_53_690 VGND VGND VPWR VPWR sky130_fd_sc_hd__fill_2
XFILLER_111_93 VGND VGND VPWR VPWR sky130_fd_sc_hd__fill_2
XFILLER_40_351 VGND VGND VPWR VPWR sky130_fd_sc_hd__decap_3
XFILLER_71_75 VGND VGND VPWR VPWR sky130_fd_sc_hd__decap_3
XFILLER_71_97 VGND VGND VPWR VPWR sky130_fd_sc_hd__decap_3
XFILLER_9_558 VGND VGND VPWR VPWR sky130_fd_sc_hd__fill_2
XFILLER_65_9 VGND VGND VPWR VPWR sky130_fd_sc_hd__fill_2
XFILLER_114_607 VGND VGND VPWR VPWR sky130_fd_sc_hd__fill_2
XFILLER_114_618 VGND VGND VPWR VPWR sky130_fd_sc_hd__decap_3
XFILLER_107_670 VGND VGND VPWR VPWR sky130_fd_sc_hd__fill_2
XFILLER_4_285 VGND VGND VPWR VPWR sky130_fd_sc_hd__decap_3
XFILLER_99_329 VGND VGND VPWR VPWR sky130_fd_sc_hd__decap_3
XFILLER_113_139 VGND VGND VPWR VPWR sky130_fd_sc_hd__decap_3
XFILLER_67_237 VGND VGND VPWR VPWR sky130_fd_sc_hd__decap_3
XFILLER_95_535 VGND VGND VPWR VPWR sky130_fd_sc_hd__decap_3
XFILLER_96_83 VGND VGND VPWR VPWR sky130_fd_sc_hd__fill_1
XFILLER_96_94 VGND VGND VPWR VPWR sky130_fd_sc_hd__decap_3
XFILLER_48_451 VGND VGND VPWR VPWR sky130_fd_sc_hd__decap_3
XFILLER_36_613 VGND VGND VPWR VPWR sky130_fd_sc_hd__fill_1
XFILLER_75_281 VGND VGND VPWR VPWR sky130_fd_sc_hd__decap_3
XFILLER_35_134 VGND VGND VPWR VPWR sky130_fd_sc_hd__decap_3
XFILLER_63_432 VGND VGND VPWR VPWR sky130_fd_sc_hd__decap_3
XFILLER_90_240 VGND VGND VPWR VPWR sky130_fd_sc_hd__decap_3
Xplace410 _4486_/S VGND VGND VPWR VPWR _4491_/S sky130_fd_sc_hd__buf_2
Xplace421 _3371_/Y VGND VGND VPWR VPWR _3399_/A sky130_fd_sc_hd__buf_2
XFILLER_23_307 VGND VGND VPWR VPWR sky130_fd_sc_hd__decap_3
XFILLER_35_189 VGND VGND VPWR VPWR sky130_fd_sc_hd__decap_3
XFILLER_63_498 VGND VGND VPWR VPWR sky130_fd_sc_hd__decap_3
Xplace432 _3996_/S VGND VGND VPWR VPWR _3994_/S sky130_fd_sc_hd__buf_2
Xplace443 _4975_/A VGND VGND VPWR VPWR _5577_/S sky130_fd_sc_hd__buf_2
Xplace454 _7010_/Q VGND VGND VPWR VPWR _7010_/D sky130_fd_sc_hd__buf_2
X_6740_ _6968_/CLK _6740_/D VGND VGND VPWR VPWR _6740_/Q sky130_fd_sc_hd__dfxtp_2
XFILLER_90_295 VGND VGND VPWR VPWR sky130_fd_sc_hd__decap_3
X_3952_ _7364_/Q _4495_/A0 _3956_/S VGND VGND VPWR VPWR _7364_/D sky130_fd_sc_hd__mux2_2
XFILLER_31_340 VGND VGND VPWR VPWR sky130_fd_sc_hd__decap_3
XFILLER_50_159 VGND VGND VPWR VPWR sky130_fd_sc_hd__decap_3
X_6671_ _6672_/A VGND VGND VPWR VPWR _6671_/Y sky130_fd_sc_hd__inv_2
X_3883_ _6814_/Q _3913_/A2 _3912_/B1 _6819_/Q VGND VGND VPWR VPWR _3883_/X sky130_fd_sc_hd__a22o_2
XTAP_TAPCELL_ROW_21_508 VGND VPWR sky130_fd_sc_hd__tapvpwrvgnd_1
X_5622_ _5622_/A _5633_/B VGND VGND VPWR VPWR _7017_/D sky130_fd_sc_hd__nor2_2
XTAP_TAPCELL_ROW_98_1429 VGND VPWR sky130_fd_sc_hd__tapvpwrvgnd_1
XFILLER_6_70 VGND VGND VPWR VPWR sky130_fd_sc_hd__decap_3
X_7223_ _7351_/CLK _7223_/D _6503_/Y VGND VGND VPWR VPWR _7223_/Q sky130_fd_sc_hd__dfrtp_2
X_4435_ _7207_/Q _3945_/S _4435_/B1 _7367_/Q VGND VGND VPWR VPWR _4435_/X sky130_fd_sc_hd__a22o_2
XFILLER_116_38 VGND VGND VPWR VPWR sky130_fd_sc_hd__decap_3
X_7154_ clkload8/A _7154_/D _6434_/Y VGND VGND VPWR VPWR _7154_/Q sky130_fd_sc_hd__dfrtp_2
X_4366_ _4460_/A _4364_/Y _4313_/D _4361_/A _4365_/X VGND VGND VPWR VPWR _4366_/X
+ sky130_fd_sc_hd__a32o_2
XFILLER_58_215 VGND VGND VPWR VPWR sky130_fd_sc_hd__decap_3
XFILLER_58_248 VGND VGND VPWR VPWR sky130_fd_sc_hd__decap_3
X_7085_ _7362_/CLK _7085_/D _6365_/Y VGND VGND VPWR VPWR _7085_/Q sky130_fd_sc_hd__dfrtp_2
X_4297_ _5113_/A _4297_/B VGND VGND VPWR VPWR _4297_/Y sky130_fd_sc_hd__nor2_2
XFILLER_98_395 VGND VGND VPWR VPWR sky130_fd_sc_hd__decap_3
XFILLER_100_345 VGND VGND VPWR VPWR sky130_fd_sc_hd__decap_3
XFILLER_73_207 VGND VGND VPWR VPWR sky130_fd_sc_hd__fill_1
XFILLER_100_389 VGND VGND VPWR VPWR sky130_fd_sc_hd__decap_3
XFILLER_26_112 VGND VGND VPWR VPWR sky130_fd_sc_hd__decap_3
XFILLER_54_421 VGND VGND VPWR VPWR sky130_fd_sc_hd__decap_3
XFILLER_73_218 VGND VGND VPWR VPWR sky130_fd_sc_hd__decap_3
XTAP_TAPCELL_ROW_57_939 VGND VPWR sky130_fd_sc_hd__tapvpwrvgnd_1
XFILLER_66_292 VGND VGND VPWR VPWR sky130_fd_sc_hd__decap_3
XFILLER_81_240 VGND VGND VPWR VPWR sky130_fd_sc_hd__decap_3
XTAP_TAPCELL_ROW_1_266 VGND VPWR sky130_fd_sc_hd__tapvpwrvgnd_1
XTAP_TAPCELL_ROW_107_1536 VGND VPWR sky130_fd_sc_hd__tapvpwrvgnd_1
XFILLER_26_156 VGND VGND VPWR VPWR sky130_fd_sc_hd__decap_3
XFILLER_41_104 VGND VGND VPWR VPWR sky130_fd_sc_hd__decap_3
XFILLER_42_605 VGND VGND VPWR VPWR sky130_fd_sc_hd__fill_1
XFILLER_54_465 VGND VGND VPWR VPWR sky130_fd_sc_hd__decap_3
XFILLER_25_57 VGND VGND VPWR VPWR sky130_fd_sc_hd__decap_3
XFILLER_41_137 VGND VGND VPWR VPWR sky130_fd_sc_hd__decap_3
X_6938_ _6966_/CLK _6938_/D VGND VGND VPWR VPWR _6938_/Q sky130_fd_sc_hd__dfxtp_2
XTAP_TAPCELL_ROW_37_696 VGND VPWR sky130_fd_sc_hd__tapvpwrvgnd_1
XFILLER_10_502 VGND VGND VPWR VPWR sky130_fd_sc_hd__decap_3
XFILLER_22_351 VGND VGND VPWR VPWR sky130_fd_sc_hd__decap_3
X_6869_ _7384_/CLK _6869_/D VGND VGND VPWR VPWR _6869_/Q sky130_fd_sc_hd__dfxtp_2
XFILLER_22_395 VGND VGND VPWR VPWR sky130_fd_sc_hd__decap_3
XFILLER_41_45 VGND VGND VPWR VPWR sky130_fd_sc_hd__fill_1
XFILLER_41_78 VGND VGND VPWR VPWR sky130_fd_sc_hd__decap_3
XFILLER_1_211 VGND VGND VPWR VPWR sky130_fd_sc_hd__decap_3
XTAP_TAPCELL_ROW_9_355 VGND VPWR sky130_fd_sc_hd__tapvpwrvgnd_1
XFILLER_9_3 VGND VGND VPWR VPWR sky130_fd_sc_hd__decap_3
Xhold591 _6786_/Q VGND VGND VPWR VPWR _6786_/D sky130_fd_sc_hd__dlygate4sd3_1
XFILLER_103_172 VGND VGND VPWR VPWR sky130_fd_sc_hd__decap_3
XFILLER_106_71 VGND VGND VPWR VPWR sky130_fd_sc_hd__decap_3
XFILLER_77_535 VGND VGND VPWR VPWR sky130_fd_sc_hd__decap_3
XFILLER_77_557 VGND VGND VPWR VPWR sky130_fd_sc_hd__decap_3
XFILLER_89_384 VGND VGND VPWR VPWR sky130_fd_sc_hd__decap_3
XFILLER_106_93 VGND VGND VPWR VPWR sky130_fd_sc_hd__decap_3
XFILLER_49_259 VGND VGND VPWR VPWR sky130_fd_sc_hd__decap_3
XFILLER_77_568 VGND VGND VPWR VPWR sky130_fd_sc_hd__decap_3
XFILLER_17_101 VGND VGND VPWR VPWR sky130_fd_sc_hd__decap_3
XFILLER_18_613 VGND VGND VPWR VPWR sky130_fd_sc_hd__decap_3
XFILLER_57_281 VGND VGND VPWR VPWR sky130_fd_sc_hd__decap_3
XFILLER_72_240 VGND VGND VPWR VPWR sky130_fd_sc_hd__decap_3
XFILLER_17_178 VGND VGND VPWR VPWR sky130_fd_sc_hd__decap_3
XFILLER_45_476 VGND VGND VPWR VPWR sky130_fd_sc_hd__decap_3
XFILLER_82_41 VGND VGND VPWR VPWR sky130_fd_sc_hd__decap_3
XFILLER_60_424 VGND VGND VPWR VPWR sky130_fd_sc_hd__decap_3
XFILLER_72_295 VGND VGND VPWR VPWR sky130_fd_sc_hd__decap_3
XFILLER_60_457 VGND VGND VPWR VPWR sky130_fd_sc_hd__decap_3
XFILLER_82_85 VGND VGND VPWR VPWR sky130_fd_sc_hd__fill_1
XFILLER_9_300 VGND VGND VPWR VPWR sky130_fd_sc_hd__fill_2
XFILLER_13_384 VGND VGND VPWR VPWR sky130_fd_sc_hd__decap_3
XFILLER_9_333 VGND VGND VPWR VPWR sky130_fd_sc_hd__decap_3
XFILLER_40_192 VGND VGND VPWR VPWR sky130_fd_sc_hd__decap_3
XFILLER_9_355 VGND VGND VPWR VPWR sky130_fd_sc_hd__decap_3
XFILLER_114_415 VGND VGND VPWR VPWR sky130_fd_sc_hd__decap_3
X_4220_ _7196_/Q _3968_/S _4354_/B1 _7388_/Q VGND VGND VPWR VPWR _4220_/X sky130_fd_sc_hd__a22o_2
XFILLER_68_557 VGND VGND VPWR VPWR sky130_fd_sc_hd__decap_3
XFILLER_95_321 VGND VGND VPWR VPWR sky130_fd_sc_hd__decap_3
X_4151_ _7019_/Q _4418_/A2 _3958_/S _7202_/Q _4150_/X VGND VGND VPWR VPWR _4151_/X
+ sky130_fd_sc_hd__a221o_2
XFILLER_55_207 VGND VGND VPWR VPWR sky130_fd_sc_hd__decap_3
XFILLER_83_505 VGND VGND VPWR VPWR sky130_fd_sc_hd__decap_3
XFILLER_95_343 VGND VGND VPWR VPWR sky130_fd_sc_hd__decap_3
X_4082_ _4082_/A _4068_/A VGND VGND VPWR VPWR _4082_/X sky130_fd_sc_hd__or2b_2
XFILLER_36_410 VGND VGND VPWR VPWR sky130_fd_sc_hd__fill_2
XFILLER_95_387 VGND VGND VPWR VPWR sky130_fd_sc_hd__decap_3
XFILLER_36_421 VGND VGND VPWR VPWR sky130_fd_sc_hd__decap_3
XFILLER_51_402 VGND VGND VPWR VPWR sky130_fd_sc_hd__decap_3
XFILLER_51_446 VGND VGND VPWR VPWR sky130_fd_sc_hd__fill_2
XFILLER_63_284 VGND VGND VPWR VPWR sky130_fd_sc_hd__decap_3
Xplace273 _3888_/B1 VGND VGND VPWR VPWR _3881_/B1 sky130_fd_sc_hd__buf_2
X_4984_ _5099_/A _4619_/Y _4624_/A VGND VGND VPWR VPWR _5031_/B sky130_fd_sc_hd__a21o_2
Xplace295 _3926_/B1 VGND VGND VPWR VPWR _3922_/A2 sky130_fd_sc_hd__buf_2
Xplace284 _3661_/X VGND VGND VPWR VPWR _3892_/A2 sky130_fd_sc_hd__buf_2
X_6723_ _6978_/CLK _6723_/D VGND VGND VPWR VPWR _6723_/Q sky130_fd_sc_hd__dfxtp_2
X_3935_ _7372_/Q _4478_/A0 _3943_/S VGND VGND VPWR VPWR _7372_/D sky130_fd_sc_hd__mux2_2
XTAP_TAPCELL_ROW_34_655 VGND VPWR sky130_fd_sc_hd__tapvpwrvgnd_1
X_6654_ _6683_/A VGND VGND VPWR VPWR _6654_/Y sky130_fd_sc_hd__inv_2
XTAP_TAPCELL_ROW_62_997 VGND VPWR sky130_fd_sc_hd__tapvpwrvgnd_1
XTAP_TAPCELL_ROW_102_1477 VGND VPWR sky130_fd_sc_hd__tapvpwrvgnd_1
XFILLER_109_209 VGND VGND VPWR VPWR sky130_fd_sc_hd__decap_3
X_5605_ _5605_/A _5605_/B VGND VGND VPWR VPWR _7025_/D sky130_fd_sc_hd__or2_2
X_3866_ _6696_/Q _6786_/Q _6874_/Q _6922_/Q _3991_/B _3665_/B VGND VGND VPWR VPWR
+ _3866_/X sky130_fd_sc_hd__mux4_2
XPHY_EDGE_ROW_12_Left_129 VGND VGND VPWR VPWR sky130_fd_sc_hd__decap_3
X_6585_ _6585_/A VGND VGND VPWR VPWR _6585_/Y sky130_fd_sc_hd__inv_2
X_3797_ _6750_/Q _3890_/A2 _3890_/B1 _6732_/Q VGND VGND VPWR VPWR _3797_/X sky130_fd_sc_hd__a22o_2
XFILLER_105_426 VGND VGND VPWR VPWR sky130_fd_sc_hd__decap_3
X_7206_ _7396_/CLK _7206_/D _6486_/Y VGND VGND VPWR VPWR _7206_/Q sky130_fd_sc_hd__dfrtp_2
X_4418_ _7023_/Q _4418_/A2 _4417_/X VGND VGND VPWR VPWR _4425_/C sky130_fd_sc_hd__a21o_2
X_5398_ _5398_/A0 _4997_/X _5398_/S VGND VGND VPWR VPWR _7134_/D sky130_fd_sc_hd__mux2_2
XTAP_TAPCELL_ROW_6_325 VGND VPWR sky130_fd_sc_hd__tapvpwrvgnd_1
XFILLER_99_671 VGND VGND VPWR VPWR sky130_fd_sc_hd__fill_1
XFILLER_101_610 VGND VGND VPWR VPWR sky130_fd_sc_hd__decap_3
XFILLER_101_632 VGND VGND VPWR VPWR sky130_fd_sc_hd__decap_3
X_7137_ _7363_/CLK _7137_/D _6417_/Y VGND VGND VPWR VPWR _7137_/Q sky130_fd_sc_hd__dfrtp_2
X_4349_ _7257_/Q _4356_/A2 _4349_/B1 _7225_/Q _4348_/X VGND VGND VPWR VPWR _4367_/A
+ sky130_fd_sc_hd__a221o_2
XFILLER_100_120 VGND VGND VPWR VPWR sky130_fd_sc_hd__decap_3
XFILLER_74_505 VGND VGND VPWR VPWR sky130_fd_sc_hd__decap_3
XFILLER_86_354 VGND VGND VPWR VPWR sky130_fd_sc_hd__decap_3
XFILLER_86_365 VGND VGND VPWR VPWR sky130_fd_sc_hd__decap_3
X_7068_ _7258_/CLK _7068_/D _6348_/Y VGND VGND VPWR VPWR _7068_/Q sky130_fd_sc_hd__dfrtp_2
XPHY_EDGE_ROW_21_Left_138 VGND VGND VPWR VPWR sky130_fd_sc_hd__decap_3
XFILLER_100_153 VGND VGND VPWR VPWR sky130_fd_sc_hd__decap_3
XFILLER_100_186 VGND VGND VPWR VPWR sky130_fd_sc_hd__decap_3
XFILLER_27_410 VGND VGND VPWR VPWR sky130_fd_sc_hd__decap_3
XFILLER_36_12 VGND VGND VPWR VPWR sky130_fd_sc_hd__decap_3
XFILLER_46_218 VGND VGND VPWR VPWR sky130_fd_sc_hd__decap_3
XFILLER_86_398 VGND VGND VPWR VPWR sky130_fd_sc_hd__decap_3
XFILLER_100_197 VGND VGND VPWR VPWR sky130_fd_sc_hd__decap_3
XFILLER_27_432 VGND VGND VPWR VPWR sky130_fd_sc_hd__fill_1
XFILLER_27_487 VGND VGND VPWR VPWR sky130_fd_sc_hd__fill_2
XFILLER_36_56 VGND VGND VPWR VPWR sky130_fd_sc_hd__decap_3
XFILLER_54_251 VGND VGND VPWR VPWR sky130_fd_sc_hd__fill_1
XFILLER_54_262 VGND VGND VPWR VPWR sky130_fd_sc_hd__decap_3
XFILLER_82_571 VGND VGND VPWR VPWR sky130_fd_sc_hd__decap_3
XTAP_TAPCELL_ROW_68_1063 VGND VPWR sky130_fd_sc_hd__tapvpwrvgnd_1
XFILLER_54_284 VGND VGND VPWR VPWR sky130_fd_sc_hd__decap_3
XFILLER_52_55 VGND VGND VPWR VPWR sky130_fd_sc_hd__fill_2
XPHY_EDGE_ROW_30_Left_147 VGND VGND VPWR VPWR sky130_fd_sc_hd__decap_3
XFILLER_10_321 VGND VGND VPWR VPWR sky130_fd_sc_hd__decap_3
XFILLER_22_192 VGND VGND VPWR VPWR sky130_fd_sc_hd__decap_3
XFILLER_52_77 VGND VGND VPWR VPWR sky130_fd_sc_hd__decap_3
XFILLER_10_354 VGND VGND VPWR VPWR sky130_fd_sc_hd__decap_3
XFILLER_10_365 VGND VGND VPWR VPWR sky130_fd_sc_hd__decap_3
XFILLER_6_303 VGND VGND VPWR VPWR sky130_fd_sc_hd__decap_3
XFILLER_108_220 VGND VGND VPWR VPWR sky130_fd_sc_hd__decap_3
XFILLER_108_253 VGND VGND VPWR VPWR sky130_fd_sc_hd__fill_1
XFILLER_6_347 VGND VGND VPWR VPWR sky130_fd_sc_hd__decap_3
XFILLER_108_275 VGND VGND VPWR VPWR sky130_fd_sc_hd__decap_3
XFILLER_2_531 VGND VGND VPWR VPWR sky130_fd_sc_hd__fill_1
XFILLER_96_118 VGND VGND VPWR VPWR sky130_fd_sc_hd__decap_3
XFILLER_111_429 VGND VGND VPWR VPWR sky130_fd_sc_hd__decap_3
XFILLER_77_52 VGND VGND VPWR VPWR sky130_fd_sc_hd__decap_3
XFILLER_77_63 VGND VGND VPWR VPWR sky130_fd_sc_hd__decap_3
XFILLER_28_9 VGND VGND VPWR VPWR sky130_fd_sc_hd__decap_3
XFILLER_65_505 VGND VGND VPWR VPWR sky130_fd_sc_hd__decap_3
XFILLER_77_343 VGND VGND VPWR VPWR sky130_fd_sc_hd__decap_3
XFILLER_37_218 VGND VGND VPWR VPWR sky130_fd_sc_hd__decap_3
XFILLER_77_376 VGND VGND VPWR VPWR sky130_fd_sc_hd__fill_1
XFILLER_77_387 VGND VGND VPWR VPWR sky130_fd_sc_hd__decap_3
XFILLER_92_324 VGND VGND VPWR VPWR sky130_fd_sc_hd__decap_3
XFILLER_65_549 VGND VGND VPWR VPWR sky130_fd_sc_hd__fill_2
XFILLER_92_346 VGND VGND VPWR VPWR sky130_fd_sc_hd__decap_3
XFILLER_93_40 VGND VGND VPWR VPWR sky130_fd_sc_hd__decap_3
XFILLER_80_519 VGND VGND VPWR VPWR sky130_fd_sc_hd__decap_3
XFILLER_92_368 VGND VGND VPWR VPWR sky130_fd_sc_hd__decap_3
XFILLER_45_284 VGND VGND VPWR VPWR sky130_fd_sc_hd__decap_3
XFILLER_60_232 VGND VGND VPWR VPWR sky130_fd_sc_hd__decap_3
XFILLER_60_265 VGND VGND VPWR VPWR sky130_fd_sc_hd__decap_3
XFILLER_20_129 VGND VGND VPWR VPWR sky130_fd_sc_hd__decap_3
XFILLER_60_298 VGND VGND VPWR VPWR sky130_fd_sc_hd__decap_3
X_3720_ _6911_/Q _3892_/A2 _3888_/B1 _6903_/Q VGND VGND VPWR VPWR _3720_/X sky130_fd_sc_hd__a22o_2
XTAP_TAPCELL_ROW_31_625 VGND VPWR sky130_fd_sc_hd__tapvpwrvgnd_1
XFILLER_13_181 VGND VGND VPWR VPWR sky130_fd_sc_hd__decap_3
Xclkbuf_leaf_40_clk clkbuf_leaf_9_clk/A VGND VGND VPWR VPWR _7381_/CLK sky130_fd_sc_hd__clkbuf_16
XFILLER_9_152 VGND VGND VPWR VPWR sky130_fd_sc_hd__decap_3
X_3651_ _3665_/A _3665_/B VGND VGND VPWR VPWR _3651_/Y sky130_fd_sc_hd__nor2_2
XFILLER_61_3 VGND VGND VPWR VPWR sky130_fd_sc_hd__decap_3
X_6370_ _6568_/A VGND VGND VPWR VPWR _6370_/Y sky130_fd_sc_hd__inv_2
X_3582_ _7348_/Q _3449_/X _3407_/X _7124_/Q VGND VGND VPWR VPWR _3583_/C sky130_fd_sc_hd__a22o_2
XTAP_TAPCELL_ROW_11_382 VGND VPWR sky130_fd_sc_hd__tapvpwrvgnd_1
XFILLER_9_196 VGND VGND VPWR VPWR sky130_fd_sc_hd__decap_3
X_5321_ _5321_/A0 _4932_/X _5327_/S VGND VGND VPWR VPWR _7170_/D sky130_fd_sc_hd__mux2_2
XFILLER_114_212 VGND VGND VPWR VPWR sky130_fd_sc_hd__fill_1
XFILLER_5_391 VGND VGND VPWR VPWR sky130_fd_sc_hd__fill_1
XFILLER_88_608 VGND VGND VPWR VPWR sky130_fd_sc_hd__fill_2
XFILLER_114_267 VGND VGND VPWR VPWR sky130_fd_sc_hd__decap_3
XFILLER_68_321 VGND VGND VPWR VPWR sky130_fd_sc_hd__decap_3
XFILLER_87_129 VGND VGND VPWR VPWR sky130_fd_sc_hd__fill_1
X_4203_ _4203_/A _4203_/B _4203_/C VGND VGND VPWR VPWR _4203_/X sky130_fd_sc_hd__and3_2
XFILLER_110_451 VGND VGND VPWR VPWR sky130_fd_sc_hd__decap_3
XFILLER_68_365 VGND VGND VPWR VPWR sky130_fd_sc_hd__decap_3
X_4134_ _7020_/Q _4422_/A2 _3958_/S _7203_/Q _4133_/X VGND VGND VPWR VPWR _4134_/X
+ sky130_fd_sc_hd__a221o_2
XFILLER_28_218 VGND VGND VPWR VPWR sky130_fd_sc_hd__fill_1
XFILLER_56_516 VGND VGND VPWR VPWR sky130_fd_sc_hd__decap_3
XFILLER_83_324 VGND VGND VPWR VPWR sky130_fd_sc_hd__decap_3
XFILLER_95_151 VGND VGND VPWR VPWR sky130_fd_sc_hd__decap_3
XFILLER_95_184 VGND VGND VPWR VPWR sky130_fd_sc_hd__decap_3
XTAP_TAPCELL_ROW_39_725 VGND VPWR sky130_fd_sc_hd__tapvpwrvgnd_1
XTAP_TAPCELL_ROW_39_714 VGND VPWR sky130_fd_sc_hd__tapvpwrvgnd_1
X_4065_ _7052_/Q _4491_/S _4399_/A2 _7404_/Q _4064_/X VGND VGND VPWR VPWR _4065_/X
+ sky130_fd_sc_hd__a221o_2
XFILLER_36_251 VGND VGND VPWR VPWR sky130_fd_sc_hd__fill_1
XFILLER_64_560 VGND VGND VPWR VPWR sky130_fd_sc_hd__decap_3
XFILLER_71_508 VGND VGND VPWR VPWR sky130_fd_sc_hd__decap_3
XFILLER_83_379 VGND VGND VPWR VPWR sky130_fd_sc_hd__decap_3
XFILLER_24_424 VGND VGND VPWR VPWR sky130_fd_sc_hd__fill_1
XFILLER_36_273 VGND VGND VPWR VPWR sky130_fd_sc_hd__decap_3
XFILLER_51_221 VGND VGND VPWR VPWR sky130_fd_sc_hd__decap_3
XTAP_TAPCELL_ROW_19_482 VGND VPWR sky130_fd_sc_hd__tapvpwrvgnd_1
XFILLER_51_287 VGND VGND VPWR VPWR sky130_fd_sc_hd__decap_3
X_4967_ _4967_/A _4967_/B VGND VGND VPWR VPWR _4967_/X sky130_fd_sc_hd__or2_2
Xclkbuf_leaf_31_clk clkbuf_3_2__f_clk/X VGND VGND VPWR VPWR _6909_/CLK sky130_fd_sc_hd__clkbuf_16
X_6706_ _7390_/CLK _6706_/D VGND VGND VPWR VPWR _6706_/Q sky130_fd_sc_hd__dfxtp_2
X_4898_ _3757_/S _3756_/X _4897_/X _5010_/A VGND VGND VPWR VPWR _4898_/X sky130_fd_sc_hd__a211o_2
X_3918_ _6915_/Q _3926_/A2 _3926_/B1 _6779_/Q _3917_/X VGND VGND VPWR VPWR _3918_/X
+ sky130_fd_sc_hd__a221o_2
XFILLER_22_47 VGND VGND VPWR VPWR sky130_fd_sc_hd__decap_3
X_6637_ _6637_/A VGND VGND VPWR VPWR _6637_/Y sky130_fd_sc_hd__inv_2
X_3849_ _6859_/Q _3926_/B1 _3925_/B1 _6899_/Q _3848_/X VGND VGND VPWR VPWR _3849_/X
+ sky130_fd_sc_hd__a221o_2
X_6568_ _6568_/A VGND VGND VPWR VPWR _6568_/Y sky130_fd_sc_hd__inv_2
XFILLER_3_317 VGND VGND VPWR VPWR sky130_fd_sc_hd__fill_2
XTAP_TAPCELL_ROW_115_1635 VGND VPWR sky130_fd_sc_hd__tapvpwrvgnd_1
XFILLER_105_223 VGND VGND VPWR VPWR sky130_fd_sc_hd__fill_1
XFILLER_105_234 VGND VGND VPWR VPWR sky130_fd_sc_hd__decap_3
X_6499_ _6599_/A VGND VGND VPWR VPWR _6499_/Y sky130_fd_sc_hd__inv_2
XFILLER_105_245 VGND VGND VPWR VPWR sky130_fd_sc_hd__decap_3
XFILLER_105_278 VGND VGND VPWR VPWR sky130_fd_sc_hd__fill_2
Xoutput471 _5657_/D VGND VGND VPWR VPWR alu_result_out[15] sky130_fd_sc_hd__clkdlybuf4s25_1
Xoutput493 _3741_/B VGND VGND VPWR VPWR alu_result_out[6] sky130_fd_sc_hd__clkdlybuf4s25_1
Xoutput482 _5663_/B VGND VGND VPWR VPWR alu_result_out[25] sky130_fd_sc_hd__clkdlybuf4s25_1
XFILLER_47_505 VGND VGND VPWR VPWR sky130_fd_sc_hd__fill_2
XFILLER_19_207 VGND VGND VPWR VPWR sky130_fd_sc_hd__decap_3
XFILLER_74_302 VGND VGND VPWR VPWR sky130_fd_sc_hd__decap_3
XFILLER_74_324 VGND VGND VPWR VPWR sky130_fd_sc_hd__fill_2
XFILLER_47_77 VGND VGND VPWR VPWR sky130_fd_sc_hd__decap_3
XFILLER_86_195 VGND VGND VPWR VPWR sky130_fd_sc_hd__fill_1
XFILLER_74_368 VGND VGND VPWR VPWR sky130_fd_sc_hd__decap_3
XFILLER_103_72 VGND VGND VPWR VPWR sky130_fd_sc_hd__decap_3
XFILLER_103_94 VGND VGND VPWR VPWR sky130_fd_sc_hd__decap_3
XFILLER_15_435 VGND VGND VPWR VPWR sky130_fd_sc_hd__fill_2
XFILLER_15_446 VGND VGND VPWR VPWR sky130_fd_sc_hd__fill_2
XFILLER_30_427 VGND VGND VPWR VPWR sky130_fd_sc_hd__decap_3
XFILLER_63_98 VGND VGND VPWR VPWR sky130_fd_sc_hd__decap_3
XFILLER_70_574 VGND VGND VPWR VPWR sky130_fd_sc_hd__decap_3
XFILLER_8_49 VGND VGND VPWR VPWR sky130_fd_sc_hd__decap_3
Xclkbuf_leaf_22_clk clkbuf_leaf_1_clk/A VGND VGND VPWR VPWR _7383_/CLK sky130_fd_sc_hd__clkbuf_16
XFILLER_10_195 VGND VGND VPWR VPWR sky130_fd_sc_hd__fill_1
XFILLER_6_144 VGND VGND VPWR VPWR sky130_fd_sc_hd__decap_3
XFILLER_12_91 VGND VGND VPWR VPWR sky130_fd_sc_hd__fill_1
XFILLER_88_73 VGND VGND VPWR VPWR sky130_fd_sc_hd__decap_3
XFILLER_97_405 VGND VGND VPWR VPWR sky130_fd_sc_hd__decap_3
XTAP_TAPCELL_ROW_90_1329 VGND VPWR sky130_fd_sc_hd__tapvpwrvgnd_1
XFILLER_111_237 VGND VGND VPWR VPWR sky130_fd_sc_hd__fill_1
XFILLER_97_449 VGND VGND VPWR VPWR sky130_fd_sc_hd__decap_3
XFILLER_26_6 VGND VGND VPWR VPWR sky130_fd_sc_hd__decap_3
XFILLER_65_313 VGND VGND VPWR VPWR sky130_fd_sc_hd__decap_3
XFILLER_93_600 VGND VGND VPWR VPWR sky130_fd_sc_hd__decap_3
XFILLER_77_195 VGND VGND VPWR VPWR sky130_fd_sc_hd__fill_2
XFILLER_92_121 VGND VGND VPWR VPWR sky130_fd_sc_hd__decap_3
XFILLER_65_379 VGND VGND VPWR VPWR sky130_fd_sc_hd__decap_3
XFILLER_92_176 VGND VGND VPWR VPWR sky130_fd_sc_hd__decap_3
XFILLER_93_688 VGND VGND VPWR VPWR sky130_fd_sc_hd__decap_3
XFILLER_18_262 VGND VGND VPWR VPWR sky130_fd_sc_hd__decap_3
XFILLER_18_295 VGND VGND VPWR VPWR sky130_fd_sc_hd__decap_3
XFILLER_33_254 VGND VGND VPWR VPWR sky130_fd_sc_hd__decap_3
X_4821_ _4832_/A _3704_/X _4819_/X _5010_/A VGND VGND VPWR VPWR _4821_/X sky130_fd_sc_hd__a211o_2
XTAP_TAPCELL_ROW_16_441 VGND VPWR sky130_fd_sc_hd__tapvpwrvgnd_1
XFILLER_21_427 VGND VGND VPWR VPWR sky130_fd_sc_hd__decap_3
XFILLER_33_287 VGND VGND VPWR VPWR sky130_fd_sc_hd__decap_3
XTAP_TAPCELL_ROW_44_783 VGND VPWR sky130_fd_sc_hd__tapvpwrvgnd_1
XFILLER_21_438 VGND VGND VPWR VPWR sky130_fd_sc_hd__decap_3
XFILLER_21_449 VGND VGND VPWR VPWR sky130_fd_sc_hd__fill_2
XFILLER_33_298 VGND VGND VPWR VPWR sky130_fd_sc_hd__decap_3
Xclkbuf_leaf_13_clk clkload0/A VGND VGND VPWR VPWR _7338_/CLK sky130_fd_sc_hd__clkbuf_16
X_4752_ _4997_/A1 _7006_/D _4751_/Y VGND VGND VPWR VPWR _4752_/X sky130_fd_sc_hd__a21o_2
X_4683_ _6997_/Q _6998_/Q _5605_/B VGND VGND VPWR VPWR _4683_/X sky130_fd_sc_hd__o21a_2
X_3703_ _6938_/Q _3828_/A2 _3825_/B1 _6802_/Q VGND VGND VPWR VPWR _3703_/X sky130_fd_sc_hd__a22o_2
X_6422_ _6616_/A VGND VGND VPWR VPWR _6422_/Y sky130_fd_sc_hd__inv_2
X_3634_ _3636_/B _3631_/Y _3632_/X _3633_/Y VGND VGND VPWR VPWR _3634_/Y sky130_fd_sc_hd__o211ai_4
X_6353_ _6388_/A VGND VGND VPWR VPWR _6353_/Y sky130_fd_sc_hd__inv_2
X_3565_ _3339_/Y _3469_/B _3564_/X _3449_/A VGND VGND VPWR VPWR _5648_/B sky130_fd_sc_hd__o211a_2
XFILLER_0_309 VGND VGND VPWR VPWR sky130_fd_sc_hd__fill_1
XFILLER_88_405 VGND VGND VPWR VPWR sky130_fd_sc_hd__fill_1
XFILLER_88_416 VGND VGND VPWR VPWR sky130_fd_sc_hd__decap_3
X_6284_ _6287_/A VGND VGND VPWR VPWR _6284_/Y sky130_fd_sc_hd__inv_2
X_5304_ _5304_/A0 _4792_/X _5325_/S VGND VGND VPWR VPWR _7178_/D sky130_fd_sc_hd__mux2_2
X_3496_ _7215_/Q _4307_/A2 _5080_/S _7279_/Q _3495_/X VGND VGND VPWR VPWR _3496_/X
+ sky130_fd_sc_hd__a221o_2
XFILLER_102_226 VGND VGND VPWR VPWR sky130_fd_sc_hd__decap_3
XFILLER_88_438 VGND VGND VPWR VPWR sky130_fd_sc_hd__decap_3
XFILLER_102_259 VGND VGND VPWR VPWR sky130_fd_sc_hd__decap_3
XFILLER_29_505 VGND VGND VPWR VPWR sky130_fd_sc_hd__decap_3
XFILLER_68_173 VGND VGND VPWR VPWR sky130_fd_sc_hd__decap_3
XFILLER_96_471 VGND VGND VPWR VPWR sky130_fd_sc_hd__decap_3
XTAP_TAPCELL_ROW_110_1576 VGND VPWR sky130_fd_sc_hd__tapvpwrvgnd_1
XFILLER_110_270 VGND VGND VPWR VPWR sky130_fd_sc_hd__fill_2
XFILLER_110_292 VGND VGND VPWR VPWR sky130_fd_sc_hd__decap_3
XFILLER_56_324 VGND VGND VPWR VPWR sky130_fd_sc_hd__decap_3
XFILLER_83_110 VGND VGND VPWR VPWR sky130_fd_sc_hd__fill_2
XFILLER_84_633 VGND VGND VPWR VPWR sky130_fd_sc_hd__decap_3
X_5097_ _6985_/Q _5120_/A VGND VGND VPWR VPWR _5098_/B sky130_fd_sc_hd__nor2_2
X_4117_ _4205_/A _4117_/B _4117_/C VGND VGND VPWR VPWR _4117_/Y sky130_fd_sc_hd__nand3_2
XFILLER_17_36 VGND VGND VPWR VPWR sky130_fd_sc_hd__decap_3
XFILLER_56_357 VGND VGND VPWR VPWR sky130_fd_sc_hd__decap_3
XFILLER_56_368 VGND VGND VPWR VPWR sky130_fd_sc_hd__decap_3
XFILLER_71_305 VGND VGND VPWR VPWR sky130_fd_sc_hd__fill_2
XFILLER_83_165 VGND VGND VPWR VPWR sky130_fd_sc_hd__decap_3
X_4048_ _7117_/Q _4434_/A2 _4434_/B1 _7149_/Q VGND VGND VPWR VPWR _4048_/X sky130_fd_sc_hd__a22o_2
XFILLER_71_349 VGND VGND VPWR VPWR sky130_fd_sc_hd__decap_3
XFILLER_24_221 VGND VGND VPWR VPWR sky130_fd_sc_hd__decap_3
XTAP_TAPCELL_ROW_65_1033 VGND VPWR sky130_fd_sc_hd__tapvpwrvgnd_1
XFILLER_12_416 VGND VGND VPWR VPWR sky130_fd_sc_hd__decap_3
XFILLER_33_57 VGND VGND VPWR VPWR sky130_fd_sc_hd__decap_3
XFILLER_33_79 VGND VGND VPWR VPWR sky130_fd_sc_hd__decap_3
XFILLER_20_471 VGND VGND VPWR VPWR sky130_fd_sc_hd__decap_3
XPHY_EDGE_ROW_104_Left_221 VGND VGND VPWR VPWR sky130_fd_sc_hd__decap_3
XFILLER_109_3 VGND VGND VPWR VPWR sky130_fd_sc_hd__decap_3
XFILLER_3_169 VGND VGND VPWR VPWR sky130_fd_sc_hd__fill_1
XFILLER_79_405 VGND VGND VPWR VPWR sky130_fd_sc_hd__decap_3
XTAP_TAPCELL_ROW_76_1162 VGND VPWR sky130_fd_sc_hd__tapvpwrvgnd_1
XFILLER_79_438 VGND VGND VPWR VPWR sky130_fd_sc_hd__decap_3
XFILLER_79_449 VGND VGND VPWR VPWR sky130_fd_sc_hd__decap_3
XFILLER_58_32 VGND VGND VPWR VPWR sky130_fd_sc_hd__decap_3
XFILLER_47_302 VGND VGND VPWR VPWR sky130_fd_sc_hd__decap_3
XFILLER_59_140 VGND VGND VPWR VPWR sky130_fd_sc_hd__decap_3
XFILLER_59_162 VGND VGND VPWR VPWR sky130_fd_sc_hd__decap_3
XFILLER_75_600 VGND VGND VPWR VPWR sky130_fd_sc_hd__decap_3
XPHY_EDGE_ROW_113_Left_230 VGND VGND VPWR VPWR sky130_fd_sc_hd__decap_3
XFILLER_47_335 VGND VGND VPWR VPWR sky130_fd_sc_hd__fill_1
XFILLER_47_346 VGND VGND VPWR VPWR sky130_fd_sc_hd__decap_3
XFILLER_74_121 VGND VGND VPWR VPWR sky130_fd_sc_hd__decap_3
XFILLER_114_71 VGND VGND VPWR VPWR sky130_fd_sc_hd__decap_3
XFILLER_74_165 VGND VGND VPWR VPWR sky130_fd_sc_hd__decap_3
XFILLER_62_338 VGND VGND VPWR VPWR sky130_fd_sc_hd__decap_3
XFILLER_15_243 VGND VGND VPWR VPWR sky130_fd_sc_hd__decap_3
XTAP_TAPCELL_ROW_87_1291 VGND VPWR sky130_fd_sc_hd__tapvpwrvgnd_1
XFILLER_15_287 VGND VGND VPWR VPWR sky130_fd_sc_hd__decap_3
XFILLER_70_371 VGND VGND VPWR VPWR sky130_fd_sc_hd__decap_3
XFILLER_95_9 VGND VGND VPWR VPWR sky130_fd_sc_hd__decap_3
XFILLER_30_246 VGND VGND VPWR VPWR sky130_fd_sc_hd__decap_3
XFILLER_90_41 VGND VGND VPWR VPWR sky130_fd_sc_hd__decap_3
XTAP_TAPCELL_ROW_41_742 VGND VPWR sky130_fd_sc_hd__tapvpwrvgnd_1
XTAP_TAPCELL_ROW_13_411 VGND VPWR sky130_fd_sc_hd__tapvpwrvgnd_1
XFILLER_11_460 VGND VGND VPWR VPWR sky130_fd_sc_hd__decap_3
XFILLER_30_268 VGND VGND VPWR VPWR sky130_fd_sc_hd__decap_3
XFILLER_90_74 VGND VGND VPWR VPWR sky130_fd_sc_hd__decap_3
XFILLER_90_85 VGND VGND VPWR VPWR sky130_fd_sc_hd__decap_3
XFILLER_7_442 VGND VGND VPWR VPWR sky130_fd_sc_hd__decap_3
XFILLER_116_307 VGND VGND VPWR VPWR sky130_fd_sc_hd__fill_1
XFILLER_116_318 VGND VGND VPWR VPWR sky130_fd_sc_hd__decap_3
XFILLER_109_370 VGND VGND VPWR VPWR sky130_fd_sc_hd__decap_3
XFILLER_99_72 VGND VGND VPWR VPWR sky130_fd_sc_hd__fill_1
X_3350_ _6979_/Q _3350_/B VGND VGND VPWR VPWR _3350_/Y sky130_fd_sc_hd__nor2_2
XFILLER_112_513 VGND VGND VPWR VPWR sky130_fd_sc_hd__decap_3
XFILLER_3_670 VGND VGND VPWR VPWR sky130_fd_sc_hd__fill_2
XFILLER_112_546 VGND VGND VPWR VPWR sky130_fd_sc_hd__decap_3
XFILLER_85_408 VGND VGND VPWR VPWR sky130_fd_sc_hd__decap_3
XFILLER_97_246 VGND VGND VPWR VPWR sky130_fd_sc_hd__decap_3
X_5020_ _5020_/A _5020_/B _4373_/Y VGND VGND VPWR VPWR _5020_/X sky130_fd_sc_hd__or3b_2
XFILLER_38_302 VGND VGND VPWR VPWR sky130_fd_sc_hd__decap_3
Xclkbuf_leaf_2_clk clkbuf_leaf_9_clk/A VGND VGND VPWR VPWR _7294_/CLK sky130_fd_sc_hd__clkbuf_16
Xhold1109 _7224_/Q VGND VGND VPWR VPWR _5209_/A sky130_fd_sc_hd__dlygate4sd3_1
XFILLER_65_110 VGND VGND VPWR VPWR sky130_fd_sc_hd__fill_2
Xsingle_cycle_cpu_583 VGND VGND VPWR VPWR single_cycle_cpu_583/HI instruction_out[29]
+ sky130_fd_sc_hd__conb_1
XTAP_TAPCELL_ROW_49_842 VGND VPWR sky130_fd_sc_hd__tapvpwrvgnd_1
XFILLER_26_519 VGND VGND VPWR VPWR sky130_fd_sc_hd__decap_3
XFILLER_53_305 VGND VGND VPWR VPWR sky130_fd_sc_hd__decap_3
XFILLER_65_165 VGND VGND VPWR VPWR sky130_fd_sc_hd__decap_3
XFILLER_81_603 VGND VGND VPWR VPWR sky130_fd_sc_hd__decap_3
XFILLER_93_452 VGND VGND VPWR VPWR sky130_fd_sc_hd__decap_3
XFILLER_0_50 VGND VGND VPWR VPWR sky130_fd_sc_hd__decap_3
XFILLER_19_571 VGND VGND VPWR VPWR sky130_fd_sc_hd__decap_3
XFILLER_65_187 VGND VGND VPWR VPWR sky130_fd_sc_hd__decap_3
XFILLER_93_496 VGND VGND VPWR VPWR sky130_fd_sc_hd__decap_3
X_6971_ _6976_/CLK _6971_/D VGND VGND VPWR VPWR _6971_/Q sky130_fd_sc_hd__dfxtp_2
XFILLER_0_72 VGND VGND VPWR VPWR sky130_fd_sc_hd__decap_3
XFILLER_34_530 VGND VGND VPWR VPWR sky130_fd_sc_hd__fill_2
XFILLER_53_349 VGND VGND VPWR VPWR sky130_fd_sc_hd__decap_3
XFILLER_80_157 VGND VGND VPWR VPWR sky130_fd_sc_hd__decap_3
XFILLER_81_669 VGND VGND VPWR VPWR sky130_fd_sc_hd__decap_3
XFILLER_21_202 VGND VGND VPWR VPWR sky130_fd_sc_hd__decap_3
XFILLER_21_246 VGND VGND VPWR VPWR sky130_fd_sc_hd__decap_3
XFILLER_61_393 VGND VGND VPWR VPWR sky130_fd_sc_hd__decap_3
X_4804_ _4804_/A _4804_/B VGND VGND VPWR VPWR _4804_/X sky130_fd_sc_hd__or2_2
X_4735_ _4735_/A0 _4734_/X _4793_/S VGND VGND VPWR VPWR _7277_/D sky130_fd_sc_hd__mux2_2
XFILLER_107_307 VGND VGND VPWR VPWR sky130_fd_sc_hd__decap_3
X_4666_ _6997_/Q _5611_/B VGND VGND VPWR VPWR _4908_/A sky130_fd_sc_hd__xnor2_2
X_7385_ _7394_/CLK _7385_/D _6665_/Y VGND VGND VPWR VPWR _7385_/Q sky130_fd_sc_hd__dfrtp_2
Xhold910 _7099_/Q VGND VGND VPWR VPWR _7099_/D sky130_fd_sc_hd__dlygate4sd3_1
Xhold921 _6715_/Q VGND VGND VPWR VPWR hold921/X sky130_fd_sc_hd__dlygate4sd3_1
X_6405_ _6567_/A VGND VGND VPWR VPWR _6405_/Y sky130_fd_sc_hd__inv_2
X_4597_ _7282_/Q _5140_/A0 _4601_/S VGND VGND VPWR VPWR _7282_/D sky130_fd_sc_hd__mux2_2
X_3617_ _4614_/C _3616_/B _4811_/C VGND VGND VPWR VPWR _3617_/X sky130_fd_sc_hd__o21a_2
Xhold932 _6699_/Q VGND VGND VPWR VPWR hold932/X sky130_fd_sc_hd__dlygate4sd3_1
Xhold954 _7041_/Q VGND VGND VPWR VPWR hold954/X sky130_fd_sc_hd__dlygate4sd3_1
Xhold943 _6700_/Q VGND VGND VPWR VPWR hold943/X sky130_fd_sc_hd__dlygate4sd3_1
X_6336_ _6347_/A VGND VGND VPWR VPWR _6336_/Y sky130_fd_sc_hd__inv_2
X_3548_ _3621_/A _4938_/A _3604_/B VGND VGND VPWR VPWR _3548_/X sky130_fd_sc_hd__or3_2
XFILLER_103_502 VGND VGND VPWR VPWR sky130_fd_sc_hd__fill_2
XFILLER_115_384 VGND VGND VPWR VPWR sky130_fd_sc_hd__decap_3
Xhold998 _7192_/Q VGND VGND VPWR VPWR hold998/X sky130_fd_sc_hd__dlygate4sd3_1
Xhold987 _7012_/Q VGND VGND VPWR VPWR _5632_/A sky130_fd_sc_hd__dlygate4sd3_1
Xhold976 _7406_/Q VGND VGND VPWR VPWR hold976/X sky130_fd_sc_hd__dlygate4sd3_1
Xhold965 _7013_/Q VGND VGND VPWR VPWR _5630_/A sky130_fd_sc_hd__dlygate4sd3_1
XFILLER_76_408 VGND VGND VPWR VPWR sky130_fd_sc_hd__decap_3
X_6267_ _6366_/A VGND VGND VPWR VPWR _6267_/Y sky130_fd_sc_hd__inv_2
X_3479_ _7152_/Q _4334_/B1 _3478_/X VGND VGND VPWR VPWR _3482_/A sky130_fd_sc_hd__a21o_2
XFILLER_103_579 VGND VGND VPWR VPWR sky130_fd_sc_hd__decap_3
XFILLER_57_600 VGND VGND VPWR VPWR sky130_fd_sc_hd__decap_3
XFILLER_88_268 VGND VGND VPWR VPWR sky130_fd_sc_hd__decap_3
XFILLER_28_24 VGND VGND VPWR VPWR sky130_fd_sc_hd__decap_3
XFILLER_28_35 VGND VGND VPWR VPWR sky130_fd_sc_hd__fill_1
XFILLER_29_313 VGND VGND VPWR VPWR sky130_fd_sc_hd__decap_3
XFILLER_29_335 VGND VGND VPWR VPWR sky130_fd_sc_hd__fill_1
XFILLER_56_110 VGND VGND VPWR VPWR sky130_fd_sc_hd__decap_3
X_5149_ _5145_/A _4852_/A _5147_/X _5148_/X VGND VGND VPWR VPWR _5149_/Y sky130_fd_sc_hd__o211ai_2
XFILLER_56_165 VGND VGND VPWR VPWR sky130_fd_sc_hd__decap_3
XFILLER_84_474 VGND VGND VPWR VPWR sky130_fd_sc_hd__fill_2
XFILLER_44_327 VGND VGND VPWR VPWR sky130_fd_sc_hd__decap_3
XFILLER_71_113 VGND VGND VPWR VPWR sky130_fd_sc_hd__fill_2
XFILLER_72_625 VGND VGND VPWR VPWR sky130_fd_sc_hd__decap_3
XFILLER_71_146 VGND VGND VPWR VPWR sky130_fd_sc_hd__decap_3
XFILLER_72_658 VGND VGND VPWR VPWR sky130_fd_sc_hd__decap_3
XFILLER_52_360 VGND VGND VPWR VPWR sky130_fd_sc_hd__decap_3
XFILLER_52_371 VGND VGND VPWR VPWR sky130_fd_sc_hd__decap_3
XFILLER_100_73 VGND VGND VPWR VPWR sky130_fd_sc_hd__decap_3
XFILLER_12_246 VGND VGND VPWR VPWR sky130_fd_sc_hd__decap_3
XFILLER_12_268 VGND VGND VPWR VPWR sky130_fd_sc_hd__decap_3
XFILLER_8_206 VGND VGND VPWR VPWR sky130_fd_sc_hd__decap_3
XFILLER_60_55 VGND VGND VPWR VPWR sky130_fd_sc_hd__decap_3
XFILLER_106_351 VGND VGND VPWR VPWR sky130_fd_sc_hd__decap_3
XFILLER_109_60 VGND VGND VPWR VPWR sky130_fd_sc_hd__decap_3
XFILLER_5_39 VGND VGND VPWR VPWR sky130_fd_sc_hd__fill_1
XFILLER_79_213 VGND VGND VPWR VPWR sky130_fd_sc_hd__decap_3
XFILLER_106_395 VGND VGND VPWR VPWR sky130_fd_sc_hd__decap_3
XFILLER_79_257 VGND VGND VPWR VPWR sky130_fd_sc_hd__decap_3
XFILLER_47_110 VGND VGND VPWR VPWR sky130_fd_sc_hd__fill_2
XFILLER_75_430 VGND VGND VPWR VPWR sky130_fd_sc_hd__decap_3
XFILLER_87_290 VGND VGND VPWR VPWR sky130_fd_sc_hd__decap_3
XFILLER_94_227 VGND VGND VPWR VPWR sky130_fd_sc_hd__decap_3
XTAP_TAPCELL_ROW_89_1320 VGND VPWR sky130_fd_sc_hd__tapvpwrvgnd_1
XFILLER_47_132 VGND VGND VPWR VPWR sky130_fd_sc_hd__decap_3
XFILLER_75_452 VGND VGND VPWR VPWR sky130_fd_sc_hd__decap_3
XFILLER_85_63 VGND VGND VPWR VPWR sky130_fd_sc_hd__decap_3
XTAP_TAPCELL_ROW_46_801 VGND VPWR sky130_fd_sc_hd__tapvpwrvgnd_1
XFILLER_47_187 VGND VGND VPWR VPWR sky130_fd_sc_hd__decap_3
XFILLER_63_625 VGND VGND VPWR VPWR sky130_fd_sc_hd__decap_3
XFILLER_85_96 VGND VGND VPWR VPWR sky130_fd_sc_hd__decap_3
XFILLER_62_157 VGND VGND VPWR VPWR sky130_fd_sc_hd__decap_3
XFILLER_63_669 VGND VGND VPWR VPWR sky130_fd_sc_hd__decap_3
XFILLER_90_455 VGND VGND VPWR VPWR sky130_fd_sc_hd__decap_3
XFILLER_31_511 VGND VGND VPWR VPWR sky130_fd_sc_hd__decap_3
XFILLER_43_371 VGND VGND VPWR VPWR sky130_fd_sc_hd__decap_3
XFILLER_43_393 VGND VGND VPWR VPWR sky130_fd_sc_hd__decap_3
XFILLER_70_190 VGND VGND VPWR VPWR sky130_fd_sc_hd__decap_3
XFILLER_93_6 VGND VGND VPWR VPWR sky130_fd_sc_hd__decap_3
XFILLER_11_290 VGND VGND VPWR VPWR sky130_fd_sc_hd__decap_3
XFILLER_7_250 VGND VGND VPWR VPWR sky130_fd_sc_hd__decap_3
X_4520_ _4520_/A0 _7287_/Q _4530_/S VGND VGND VPWR VPWR _7319_/D sky130_fd_sc_hd__mux2_2
X_4451_ _4451_/A _4451_/B VGND VGND VPWR VPWR _4765_/B sky130_fd_sc_hd__nor2_2
X_7170_ _7362_/CLK _7170_/D _6450_/Y VGND VGND VPWR VPWR _7170_/Q sky130_fd_sc_hd__dfrtp_2
X_3402_ _3385_/Y _3401_/X _4307_/A2 VGND VGND VPWR VPWR _3421_/C sky130_fd_sc_hd__a21oi_4
X_4382_ _4950_/A _4967_/B VGND VGND VPWR VPWR _4383_/C sky130_fd_sc_hd__nor2_2
XFILLER_98_533 VGND VGND VPWR VPWR sky130_fd_sc_hd__decap_3
XFILLER_98_522 VGND VGND VPWR VPWR sky130_fd_sc_hd__decap_3
XFILLER_112_332 VGND VGND VPWR VPWR sky130_fd_sc_hd__decap_3
XFILLER_98_566 VGND VGND VPWR VPWR sky130_fd_sc_hd__decap_3
XFILLER_112_365 VGND VGND VPWR VPWR sky130_fd_sc_hd__decap_3
XPHY_EDGE_ROW_7_Right_7 VGND VGND VPWR VPWR sky130_fd_sc_hd__decap_3
XFILLER_98_599 VGND VGND VPWR VPWR sky130_fd_sc_hd__decap_3
XFILLER_112_398 VGND VGND VPWR VPWR sky130_fd_sc_hd__decap_3
XFILLER_38_121 VGND VGND VPWR VPWR sky130_fd_sc_hd__decap_3
XFILLER_66_430 VGND VGND VPWR VPWR sky130_fd_sc_hd__decap_3
X_5003_ _5003_/A _5003_/B VGND VGND VPWR VPWR _5003_/X sky130_fd_sc_hd__or2_2
XFILLER_26_305 VGND VGND VPWR VPWR sky130_fd_sc_hd__decap_3
XFILLER_26_338 VGND VGND VPWR VPWR sky130_fd_sc_hd__decap_3
XFILLER_38_165 VGND VGND VPWR VPWR sky130_fd_sc_hd__decap_3
XFILLER_53_102 VGND VGND VPWR VPWR sky130_fd_sc_hd__decap_3
XFILLER_53_113 VGND VGND VPWR VPWR sky130_fd_sc_hd__decap_3
XFILLER_93_271 VGND VGND VPWR VPWR sky130_fd_sc_hd__decap_3
XFILLER_19_390 VGND VGND VPWR VPWR sky130_fd_sc_hd__fill_2
XFILLER_81_455 VGND VGND VPWR VPWR sky130_fd_sc_hd__decap_3
X_6954_ _6966_/CLK _6954_/D VGND VGND VPWR VPWR _6954_/Q sky130_fd_sc_hd__dfxtp_2
XFILLER_34_360 VGND VGND VPWR VPWR sky130_fd_sc_hd__decap_3
XFILLER_41_308 VGND VGND VPWR VPWR sky130_fd_sc_hd__decap_3
XFILLER_81_488 VGND VGND VPWR VPWR sky130_fd_sc_hd__decap_3
XFILLER_22_533 VGND VGND VPWR VPWR sky130_fd_sc_hd__decap_3
XFILLER_34_371 VGND VGND VPWR VPWR sky130_fd_sc_hd__fill_2
X_6885_ _7198_/CLK _6885_/D VGND VGND VPWR VPWR _6885_/Q sky130_fd_sc_hd__dfxtp_2
XTAP_TAPCELL_ROW_24_539 VGND VPWR sky130_fd_sc_hd__tapvpwrvgnd_1
XFILLER_14_48 VGND VGND VPWR VPWR sky130_fd_sc_hd__fill_2
XFILLER_14_59 VGND VGND VPWR VPWR sky130_fd_sc_hd__decap_3
XFILLER_61_190 VGND VGND VPWR VPWR sky130_fd_sc_hd__decap_3
X_4718_ _4718_/A0 _4716_/X _4793_/S VGND VGND VPWR VPWR _7278_/D sky130_fd_sc_hd__mux2_4
X_4649_ _4649_/A _4649_/B _4425_/C VGND VGND VPWR VPWR _4652_/A sky130_fd_sc_hd__nor3b_2
XFILLER_107_159 VGND VGND VPWR VPWR sky130_fd_sc_hd__decap_3
XFILLER_30_58 VGND VGND VPWR VPWR sky130_fd_sc_hd__decap_3
XFILLER_116_682 VGND VGND VPWR VPWR sky130_fd_sc_hd__fill_2
XFILLER_89_500 VGND VGND VPWR VPWR sky130_fd_sc_hd__decap_3
XFILLER_89_511 VGND VGND VPWR VPWR sky130_fd_sc_hd__decap_3
X_7368_ _7368_/CLK _7368_/D _6648_/Y VGND VGND VPWR VPWR _7368_/Q sky130_fd_sc_hd__dfrtp_2
Xhold740 _6950_/Q VGND VGND VPWR VPWR _6950_/D sky130_fd_sc_hd__dlygate4sd3_1
Xhold751 _6801_/Q VGND VGND VPWR VPWR _6801_/D sky130_fd_sc_hd__dlygate4sd3_1
Xhold762 _6721_/Q VGND VGND VPWR VPWR _6721_/D sky130_fd_sc_hd__dlygate4sd3_1
Xhold773 _6919_/Q VGND VGND VPWR VPWR _6919_/D sky130_fd_sc_hd__dlygate4sd3_1
XTAP_TAPCELL_ROW_73_1132 VGND VPWR sky130_fd_sc_hd__tapvpwrvgnd_1
XFILLER_103_332 VGND VGND VPWR VPWR sky130_fd_sc_hd__decap_3
XFILLER_103_343 VGND VGND VPWR VPWR sky130_fd_sc_hd__decap_3
XFILLER_89_555 VGND VGND VPWR VPWR sky130_fd_sc_hd__decap_3
X_7299_ _7363_/CLK _7299_/D _6579_/Y VGND VGND VPWR VPWR _7299_/Q sky130_fd_sc_hd__dfrtp_2
Xhold784 _6960_/Q VGND VGND VPWR VPWR _6960_/D sky130_fd_sc_hd__dlygate4sd3_1
Xhold795 _6899_/Q VGND VGND VPWR VPWR _6899_/D sky130_fd_sc_hd__dlygate4sd3_1
X_6319_ _6674_/A VGND VGND VPWR VPWR _6319_/Y sky130_fd_sc_hd__inv_2
XFILLER_103_376 VGND VGND VPWR VPWR sky130_fd_sc_hd__decap_3
XFILLER_49_419 VGND VGND VPWR VPWR sky130_fd_sc_hd__decap_3
XFILLER_76_238 VGND VGND VPWR VPWR sky130_fd_sc_hd__decap_3
XFILLER_29_143 VGND VGND VPWR VPWR sky130_fd_sc_hd__decap_3
XFILLER_57_452 VGND VGND VPWR VPWR sky130_fd_sc_hd__decap_3
XFILLER_69_290 VGND VGND VPWR VPWR sky130_fd_sc_hd__decap_3
XFILLER_29_187 VGND VGND VPWR VPWR sky130_fd_sc_hd__decap_3
XFILLER_44_113 VGND VGND VPWR VPWR sky130_fd_sc_hd__fill_1
XFILLER_45_625 VGND VGND VPWR VPWR sky130_fd_sc_hd__fill_2
XFILLER_55_22 VGND VGND VPWR VPWR sky130_fd_sc_hd__decap_3
XFILLER_57_474 VGND VGND VPWR VPWR sky130_fd_sc_hd__decap_3
XFILLER_84_282 VGND VGND VPWR VPWR sky130_fd_sc_hd__decap_3
XTAP_TAPCELL_ROW_4_297 VGND VPWR sky130_fd_sc_hd__tapvpwrvgnd_1
XFILLER_45_669 VGND VGND VPWR VPWR sky130_fd_sc_hd__decap_3
XFILLER_55_66 VGND VGND VPWR VPWR sky130_fd_sc_hd__fill_1
XFILLER_72_433 VGND VGND VPWR VPWR sky130_fd_sc_hd__decap_3
XFILLER_44_157 VGND VGND VPWR VPWR sky130_fd_sc_hd__decap_3
XFILLER_72_466 VGND VGND VPWR VPWR sky130_fd_sc_hd__decap_3
XFILLER_72_477 VGND VGND VPWR VPWR sky130_fd_sc_hd__decap_3
XTAP_TAPCELL_ROW_84_1261 VGND VPWR sky130_fd_sc_hd__tapvpwrvgnd_1
XFILLER_111_72 VGND VGND VPWR VPWR sky130_fd_sc_hd__decap_3
XFILLER_25_382 VGND VGND VPWR VPWR sky130_fd_sc_hd__decap_3
XFILLER_25_393 VGND VGND VPWR VPWR sky130_fd_sc_hd__decap_3
XFILLER_40_330 VGND VGND VPWR VPWR sky130_fd_sc_hd__decap_3
XFILLER_40_363 VGND VGND VPWR VPWR sky130_fd_sc_hd__fill_1
XFILLER_40_374 VGND VGND VPWR VPWR sky130_fd_sc_hd__decap_3
XFILLER_40_396 VGND VGND VPWR VPWR sky130_fd_sc_hd__decap_3
XFILLER_58_9 VGND VGND VPWR VPWR sky130_fd_sc_hd__fill_1
XFILLER_4_264 VGND VGND VPWR VPWR sky130_fd_sc_hd__decap_3
XTAP_TAPCELL_ROW_95_1390 VGND VPWR sky130_fd_sc_hd__tapvpwrvgnd_1
XFILLER_106_192 VGND VGND VPWR VPWR sky130_fd_sc_hd__decap_3
XFILLER_4_297 VGND VGND VPWR VPWR sky130_fd_sc_hd__decap_3
XFILLER_95_503 VGND VGND VPWR VPWR sky130_fd_sc_hd__fill_1
XFILLER_95_514 VGND VGND VPWR VPWR sky130_fd_sc_hd__decap_3
XFILLER_96_40 VGND VGND VPWR VPWR sky130_fd_sc_hd__decap_3
XFILLER_96_62 VGND VGND VPWR VPWR sky130_fd_sc_hd__decap_3
XFILLER_67_216 VGND VGND VPWR VPWR sky130_fd_sc_hd__decap_3
XFILLER_67_249 VGND VGND VPWR VPWR sky130_fd_sc_hd__decap_3
XFILLER_95_547 VGND VGND VPWR VPWR sky130_fd_sc_hd__decap_3
XFILLER_48_430 VGND VGND VPWR VPWR sky130_fd_sc_hd__decap_3
XFILLER_48_463 VGND VGND VPWR VPWR sky130_fd_sc_hd__fill_2
XFILLER_35_102 VGND VGND VPWR VPWR sky130_fd_sc_hd__fill_2
XFILLER_35_113 VGND VGND VPWR VPWR sky130_fd_sc_hd__decap_3
XFILLER_48_474 VGND VGND VPWR VPWR sky130_fd_sc_hd__fill_2
XFILLER_63_411 VGND VGND VPWR VPWR sky130_fd_sc_hd__decap_3
XFILLER_35_146 VGND VGND VPWR VPWR sky130_fd_sc_hd__fill_1
XFILLER_63_444 VGND VGND VPWR VPWR sky130_fd_sc_hd__decap_3
XFILLER_63_455 VGND VGND VPWR VPWR sky130_fd_sc_hd__fill_1
Xplace400 _7412_/A VGND VGND VPWR VPWR _5340_/S sky130_fd_sc_hd__buf_2
Xplace411 _4486_/S VGND VGND VPWR VPWR _4488_/S sky130_fd_sc_hd__buf_2
Xplace422 _4414_/B1 VGND VGND VPWR VPWR _3956_/S sky130_fd_sc_hd__buf_2
XFILLER_51_617 VGND VGND VPWR VPWR sky130_fd_sc_hd__fill_2
XFILLER_90_274 VGND VGND VPWR VPWR sky130_fd_sc_hd__decap_3
Xplace433 _4414_/B1 VGND VGND VPWR VPWR _3996_/S sky130_fd_sc_hd__buf_2
Xplace444 _4975_/A VGND VGND VPWR VPWR _4983_/A sky130_fd_sc_hd__buf_2
Xplace455 _6983_/Q VGND VGND VPWR VPWR _4697_/A sky130_fd_sc_hd__buf_2
XFILLER_16_371 VGND VGND VPWR VPWR sky130_fd_sc_hd__decap_3
XFILLER_43_190 VGND VGND VPWR VPWR sky130_fd_sc_hd__decap_3
XFILLER_91_3 VGND VGND VPWR VPWR sky130_fd_sc_hd__decap_3
X_6670_ _6670_/A VGND VGND VPWR VPWR _6670_/Y sky130_fd_sc_hd__inv_2
X_3882_ _6974_/Q _3882_/A2 _3889_/B1 _6969_/Q _3881_/X VGND VGND VPWR VPWR _3882_/X
+ sky130_fd_sc_hd__a221o_2
XTAP_TAPCELL_ROW_21_509 VGND VPWR sky130_fd_sc_hd__tapvpwrvgnd_1
XFILLER_31_385 VGND VGND VPWR VPWR sky130_fd_sc_hd__decap_3
X_5621_ _5621_/A VGND VGND VPWR VPWR _5622_/A sky130_fd_sc_hd__inv_2
X_4503_ _7328_/Q _7296_/Q _4507_/S VGND VGND VPWR VPWR _7328_/D sky130_fd_sc_hd__mux2_2
X_7222_ clkload2/A _7222_/D _6502_/Y VGND VGND VPWR VPWR _7222_/Q sky130_fd_sc_hd__dfrtp_2
X_4434_ _7111_/Q _4434_/A2 _4434_/B1 _7143_/Q _4433_/X VGND VGND VPWR VPWR _4434_/X
+ sky130_fd_sc_hd__a221o_2
X_7153_ clkload7/A _7153_/D _6433_/Y VGND VGND VPWR VPWR _7153_/Q sky130_fd_sc_hd__dfrtp_2
X_4365_ _4365_/A _4365_/B _4365_/C VGND VGND VPWR VPWR _4365_/X sky130_fd_sc_hd__and3_2
XFILLER_86_503 VGND VGND VPWR VPWR sky130_fd_sc_hd__decap_3
XFILLER_86_514 VGND VGND VPWR VPWR sky130_fd_sc_hd__decap_3
X_7084_ _7330_/CLK _7084_/D _6364_/Y VGND VGND VPWR VPWR _7084_/Q sky130_fd_sc_hd__dfrtp_2
X_3316_ _3365_/A _6983_/Q VGND VGND VPWR VPWR _3332_/B sky130_fd_sc_hd__nor2b_2
XFILLER_112_195 VGND VGND VPWR VPWR sky130_fd_sc_hd__fill_1
XFILLER_58_227 VGND VGND VPWR VPWR sky130_fd_sc_hd__decap_3
XFILLER_86_536 VGND VGND VPWR VPWR sky130_fd_sc_hd__decap_3
X_4296_ _4292_/A _3591_/Y _4295_/X VGND VGND VPWR VPWR _4297_/B sky130_fd_sc_hd__a21oi_2
XFILLER_100_357 VGND VGND VPWR VPWR sky130_fd_sc_hd__decap_3
XFILLER_100_368 VGND VGND VPWR VPWR sky130_fd_sc_hd__decap_3
XFILLER_27_614 VGND VGND VPWR VPWR sky130_fd_sc_hd__fill_2
XFILLER_54_400 VGND VGND VPWR VPWR sky130_fd_sc_hd__decap_3
XFILLER_26_124 VGND VGND VPWR VPWR sky130_fd_sc_hd__decap_3
XTAP_TAPCELL_ROW_1_267 VGND VPWR sky130_fd_sc_hd__tapvpwrvgnd_1
XTAP_TAPCELL_ROW_107_1537 VGND VPWR sky130_fd_sc_hd__tapvpwrvgnd_1
XFILLER_25_36 VGND VGND VPWR VPWR sky130_fd_sc_hd__decap_3
XFILLER_26_179 VGND VGND VPWR VPWR sky130_fd_sc_hd__decap_3
XFILLER_54_477 VGND VGND VPWR VPWR sky130_fd_sc_hd__decap_3
XFILLER_81_263 VGND VGND VPWR VPWR sky130_fd_sc_hd__fill_2
XFILLER_41_116 VGND VGND VPWR VPWR sky130_fd_sc_hd__decap_3
XFILLER_81_296 VGND VGND VPWR VPWR sky130_fd_sc_hd__fill_1
X_6937_ _6966_/CLK _6937_/D VGND VGND VPWR VPWR _6937_/Q sky130_fd_sc_hd__dfxtp_2
XTAP_TAPCELL_ROW_37_697 VGND VPWR sky130_fd_sc_hd__tapvpwrvgnd_1
X_6868_ _6936_/CLK _6868_/D VGND VGND VPWR VPWR _6868_/Q sky130_fd_sc_hd__dfxtp_2
XFILLER_22_363 VGND VGND VPWR VPWR sky130_fd_sc_hd__fill_1
XFILLER_22_374 VGND VGND VPWR VPWR sky130_fd_sc_hd__decap_3
XFILLER_41_57 VGND VGND VPWR VPWR sky130_fd_sc_hd__decap_3
X_6799_ _7406_/CLK _6799_/D VGND VGND VPWR VPWR _6799_/Q sky130_fd_sc_hd__dfxtp_2
XFILLER_108_424 VGND VGND VPWR VPWR sky130_fd_sc_hd__decap_3
XFILLER_108_468 VGND VGND VPWR VPWR sky130_fd_sc_hd__decap_3
XFILLER_104_641 VGND VGND VPWR VPWR sky130_fd_sc_hd__decap_3
XTAP_TAPCELL_ROW_9_356 VGND VPWR sky130_fd_sc_hd__tapvpwrvgnd_1
XFILLER_77_514 VGND VGND VPWR VPWR sky130_fd_sc_hd__decap_3
Xhold592 _6856_/Q VGND VGND VPWR VPWR _6856_/D sky130_fd_sc_hd__dlygate4sd3_1
XFILLER_103_184 VGND VGND VPWR VPWR sky130_fd_sc_hd__decap_3
XFILLER_106_61 VGND VGND VPWR VPWR sky130_fd_sc_hd__decap_3
XFILLER_89_396 VGND VGND VPWR VPWR sky130_fd_sc_hd__decap_3
XFILLER_106_83 VGND VGND VPWR VPWR sky130_fd_sc_hd__fill_1
XFILLER_66_32 VGND VGND VPWR VPWR sky130_fd_sc_hd__decap_3
XFILLER_45_411 VGND VGND VPWR VPWR sky130_fd_sc_hd__decap_3
XFILLER_64_208 VGND VGND VPWR VPWR sky130_fd_sc_hd__decap_3
XFILLER_66_65 VGND VGND VPWR VPWR sky130_fd_sc_hd__decap_3
XFILLER_92_539 VGND VGND VPWR VPWR sky130_fd_sc_hd__decap_3
XFILLER_45_455 VGND VGND VPWR VPWR sky130_fd_sc_hd__decap_3
XFILLER_57_293 VGND VGND VPWR VPWR sky130_fd_sc_hd__decap_3
XFILLER_66_98 VGND VGND VPWR VPWR sky130_fd_sc_hd__fill_2
XFILLER_45_488 VGND VGND VPWR VPWR sky130_fd_sc_hd__fill_1
XFILLER_60_403 VGND VGND VPWR VPWR sky130_fd_sc_hd__decap_3
XFILLER_32_127 VGND VGND VPWR VPWR sky130_fd_sc_hd__decap_3
XFILLER_60_436 VGND VGND VPWR VPWR sky130_fd_sc_hd__decap_3
XFILLER_72_274 VGND VGND VPWR VPWR sky130_fd_sc_hd__decap_3
XFILLER_25_190 VGND VGND VPWR VPWR sky130_fd_sc_hd__decap_3
XFILLER_60_469 VGND VGND VPWR VPWR sky130_fd_sc_hd__decap_3
XFILLER_15_80 VGND VGND VPWR VPWR sky130_fd_sc_hd__decap_3
XFILLER_40_171 VGND VGND VPWR VPWR sky130_fd_sc_hd__decap_3
XFILLER_13_396 VGND VGND VPWR VPWR sky130_fd_sc_hd__decap_3
XFILLER_9_367 VGND VGND VPWR VPWR sky130_fd_sc_hd__decap_3
XFILLER_114_427 VGND VGND VPWR VPWR sky130_fd_sc_hd__decap_3
XFILLER_56_6 VGND VGND VPWR VPWR sky130_fd_sc_hd__decap_3
XFILLER_99_116 VGND VGND VPWR VPWR sky130_fd_sc_hd__fill_1
XFILLER_99_105 VGND VGND VPWR VPWR sky130_fd_sc_hd__decap_3
XFILLER_114_449 VGND VGND VPWR VPWR sky130_fd_sc_hd__decap_3
XFILLER_99_138 VGND VGND VPWR VPWR sky130_fd_sc_hd__decap_3
XFILLER_68_503 VGND VGND VPWR VPWR sky130_fd_sc_hd__decap_3
XFILLER_68_514 VGND VGND VPWR VPWR sky130_fd_sc_hd__decap_3
X_4150_ _7234_/Q _4469_/A3 _4394_/B _7362_/Q VGND VGND VPWR VPWR _4150_/X sky130_fd_sc_hd__a22o_2
XFILLER_110_611 VGND VGND VPWR VPWR sky130_fd_sc_hd__decap_3
XFILLER_110_622 VGND VGND VPWR VPWR sky130_fd_sc_hd__decap_3
XFILLER_68_536 VGND VGND VPWR VPWR sky130_fd_sc_hd__decap_3
XFILLER_68_569 VGND VGND VPWR VPWR sky130_fd_sc_hd__decap_3
X_4081_ _4451_/A _4451_/B VGND VGND VPWR VPWR _4081_/X sky130_fd_sc_hd__or2b_2
XFILLER_55_219 VGND VGND VPWR VPWR sky130_fd_sc_hd__decap_3
XFILLER_83_517 VGND VGND VPWR VPWR sky130_fd_sc_hd__decap_3
XFILLER_95_399 VGND VGND VPWR VPWR sky130_fd_sc_hd__decap_3
XFILLER_24_628 VGND VGND VPWR VPWR sky130_fd_sc_hd__fill_1
XFILLER_36_455 VGND VGND VPWR VPWR sky130_fd_sc_hd__decap_3
XFILLER_63_252 VGND VGND VPWR VPWR sky130_fd_sc_hd__fill_1
XFILLER_91_561 VGND VGND VPWR VPWR sky130_fd_sc_hd__decap_3
XFILLER_23_116 VGND VGND VPWR VPWR sky130_fd_sc_hd__decap_3
XFILLER_23_138 VGND VGND VPWR VPWR sky130_fd_sc_hd__fill_2
XFILLER_63_296 VGND VGND VPWR VPWR sky130_fd_sc_hd__decap_3
Xplace263 _4926_/Y VGND VGND VPWR VPWR _5656_/C sky130_fd_sc_hd__buf_2
X_4983_ _4983_/A _4983_/B _4983_/C VGND VGND VPWR VPWR _4983_/X sky130_fd_sc_hd__and3_2
XFILLER_23_149 VGND VGND VPWR VPWR sky130_fd_sc_hd__decap_3
XFILLER_51_458 VGND VGND VPWR VPWR sky130_fd_sc_hd__decap_3
Xplace296 _3893_/A2 VGND VGND VPWR VPWR _3926_/B1 sky130_fd_sc_hd__buf_2
Xplace285 _3661_/X VGND VGND VPWR VPWR _3852_/A2 sky130_fd_sc_hd__buf_2
Xplace274 _3892_/B1 VGND VGND VPWR VPWR _3888_/B1 sky130_fd_sc_hd__buf_2
X_6722_ _6972_/CLK _6722_/D VGND VGND VPWR VPWR _6722_/Q sky130_fd_sc_hd__dfxtp_2
XTAP_TAPCELL_ROW_34_656 VGND VPWR sky130_fd_sc_hd__tapvpwrvgnd_1
X_6653_ _6683_/A VGND VGND VPWR VPWR _6653_/Y sky130_fd_sc_hd__inv_2
XTAP_TAPCELL_ROW_62_998 VGND VPWR sky130_fd_sc_hd__tapvpwrvgnd_1
XTAP_TAPCELL_ROW_102_1478 VGND VPWR sky130_fd_sc_hd__tapvpwrvgnd_1
XFILLER_31_182 VGND VGND VPWR VPWR sky130_fd_sc_hd__decap_3
X_6584_ _6584_/A VGND VGND VPWR VPWR _6584_/Y sky130_fd_sc_hd__inv_2
X_3796_ _6726_/Q _3890_/A2 _3882_/A2 _6976_/Q _3795_/X VGND VGND VPWR VPWR _3796_/X
+ sky130_fd_sc_hd__a221o_2
XFILLER_105_449 VGND VGND VPWR VPWR sky130_fd_sc_hd__decap_3
X_7205_ _7359_/CLK _7205_/D _6485_/Y VGND VGND VPWR VPWR _7205_/Q sky130_fd_sc_hd__dfrtp_2
X_4417_ _7304_/Q _4417_/A2 _4434_/A2 _7112_/Q _4416_/X VGND VGND VPWR VPWR _4417_/X
+ sky130_fd_sc_hd__a221o_2
XTAP_TAPCELL_ROW_6_326 VGND VPWR sky130_fd_sc_hd__tapvpwrvgnd_1
XFILLER_59_514 VGND VGND VPWR VPWR sky130_fd_sc_hd__decap_3
XFILLER_59_536 VGND VGND VPWR VPWR sky130_fd_sc_hd__decap_3
X_7136_ _7359_/CLK _7136_/D _6416_/Y VGND VGND VPWR VPWR _7136_/Q sky130_fd_sc_hd__dfrtp_2
X_4348_ _7161_/Q _4348_/A2 _4348_/B1 _7129_/Q _4347_/X VGND VGND VPWR VPWR _4348_/X
+ sky130_fd_sc_hd__a221o_2
XFILLER_59_569 VGND VGND VPWR VPWR sky130_fd_sc_hd__decap_3
XFILLER_86_333 VGND VGND VPWR VPWR sky130_fd_sc_hd__decap_3
X_7067_ _7258_/CLK _7067_/D _6347_/Y VGND VGND VPWR VPWR _7067_/Q sky130_fd_sc_hd__dfrtp_2
X_4279_ _7318_/Q _3399_/A _4348_/B1 _7126_/Q VGND VGND VPWR VPWR _4279_/X sky130_fd_sc_hd__a22o_2
XFILLER_74_517 VGND VGND VPWR VPWR sky130_fd_sc_hd__decap_3
XFILLER_74_539 VGND VGND VPWR VPWR sky130_fd_sc_hd__decap_3
XFILLER_86_377 VGND VGND VPWR VPWR sky130_fd_sc_hd__decap_3
XFILLER_36_35 VGND VGND VPWR VPWR sky130_fd_sc_hd__fill_1
XFILLER_54_230 VGND VGND VPWR VPWR sky130_fd_sc_hd__decap_3
XFILLER_67_591 VGND VGND VPWR VPWR sky130_fd_sc_hd__decap_3
XFILLER_36_68 VGND VGND VPWR VPWR sky130_fd_sc_hd__fill_1
XTAP_TAPCELL_ROW_68_1064 VGND VPWR sky130_fd_sc_hd__tapvpwrvgnd_1
XFILLER_54_296 VGND VGND VPWR VPWR sky130_fd_sc_hd__decap_3
XFILLER_82_583 VGND VGND VPWR VPWR sky130_fd_sc_hd__decap_3
XFILLER_14_138 VGND VGND VPWR VPWR sky130_fd_sc_hd__fill_2
XTAP_TAPCELL_ROW_81_1220 VGND VPWR sky130_fd_sc_hd__tapvpwrvgnd_1
XFILLER_10_377 VGND VGND VPWR VPWR sky130_fd_sc_hd__fill_2
XFILLER_108_232 VGND VGND VPWR VPWR sky130_fd_sc_hd__fill_2
XFILLER_108_243 VGND VGND VPWR VPWR sky130_fd_sc_hd__fill_2
XTAP_TAPCELL_ROW_92_1360 VGND VPWR sky130_fd_sc_hd__tapvpwrvgnd_1
XFILLER_77_322 VGND VGND VPWR VPWR sky130_fd_sc_hd__decap_3
XFILLER_89_160 VGND VGND VPWR VPWR sky130_fd_sc_hd__decap_3
XFILLER_77_355 VGND VGND VPWR VPWR sky130_fd_sc_hd__decap_3
XFILLER_77_75 VGND VGND VPWR VPWR sky130_fd_sc_hd__fill_2
XFILLER_65_517 VGND VGND VPWR VPWR sky130_fd_sc_hd__decap_3
XFILLER_77_399 VGND VGND VPWR VPWR sky130_fd_sc_hd__decap_3
XFILLER_92_336 VGND VGND VPWR VPWR sky130_fd_sc_hd__fill_1
XFILLER_92_358 VGND VGND VPWR VPWR sky130_fd_sc_hd__decap_3
XFILLER_18_466 VGND VGND VPWR VPWR sky130_fd_sc_hd__fill_2
XFILLER_18_477 VGND VGND VPWR VPWR sky130_fd_sc_hd__decap_3
XFILLER_73_572 VGND VGND VPWR VPWR sky130_fd_sc_hd__decap_3
XFILLER_93_63 VGND VGND VPWR VPWR sky130_fd_sc_hd__decap_3
XFILLER_33_425 VGND VGND VPWR VPWR sky130_fd_sc_hd__decap_3
XFILLER_33_436 VGND VGND VPWR VPWR sky130_fd_sc_hd__fill_2
XFILLER_45_296 VGND VGND VPWR VPWR sky130_fd_sc_hd__decap_3
XFILLER_60_200 VGND VGND VPWR VPWR sky130_fd_sc_hd__fill_1
XFILLER_60_211 VGND VGND VPWR VPWR sky130_fd_sc_hd__decap_3
XFILLER_93_85 VGND VGND VPWR VPWR sky130_fd_sc_hd__decap_3
XFILLER_33_447 VGND VGND VPWR VPWR sky130_fd_sc_hd__fill_1
XFILLER_33_458 VGND VGND VPWR VPWR sky130_fd_sc_hd__decap_3
XFILLER_60_244 VGND VGND VPWR VPWR sky130_fd_sc_hd__decap_3
XFILLER_20_108 VGND VGND VPWR VPWR sky130_fd_sc_hd__decap_3
XTAP_TAPCELL_ROW_31_626 VGND VPWR sky130_fd_sc_hd__tapvpwrvgnd_1
XFILLER_13_193 VGND VGND VPWR VPWR sky130_fd_sc_hd__decap_3
XFILLER_9_131 VGND VGND VPWR VPWR sky130_fd_sc_hd__decap_3
X_3650_ _3991_/B VGND VGND VPWR VPWR _3665_/A sky130_fd_sc_hd__inv_2
XFILLER_9_175 VGND VGND VPWR VPWR sky130_fd_sc_hd__decap_3
XFILLER_9_164 VGND VGND VPWR VPWR sky130_fd_sc_hd__decap_3
X_3581_ _7156_/Q _3409_/X _3579_/X _3580_/X VGND VGND VPWR VPWR _3583_/B sky130_fd_sc_hd__a211o_2
XTAP_TAPCELL_ROW_11_383 VGND VPWR sky130_fd_sc_hd__tapvpwrvgnd_1
XFILLER_54_3 VGND VGND VPWR VPWR sky130_fd_sc_hd__decap_3
XFILLER_5_370 VGND VGND VPWR VPWR sky130_fd_sc_hd__decap_3
X_5251_ _5251_/A0 _4899_/X _5262_/S VGND VGND VPWR VPWR _7204_/D sky130_fd_sc_hd__mux2_2
XFILLER_102_408 VGND VGND VPWR VPWR sky130_fd_sc_hd__decap_3
X_4202_ _4202_/A VGND VGND VPWR VPWR _4203_/C sky130_fd_sc_hd__inv_2
XFILLER_68_300 VGND VGND VPWR VPWR sky130_fd_sc_hd__decap_3
X_5182_ _7237_/Q _5190_/B VGND VGND VPWR VPWR _7237_/D sky130_fd_sc_hd__and2_2
XFILLER_110_430 VGND VGND VPWR VPWR sky130_fd_sc_hd__decap_3
XFILLER_68_344 VGND VGND VPWR VPWR sky130_fd_sc_hd__decap_3
XFILLER_95_130 VGND VGND VPWR VPWR sky130_fd_sc_hd__decap_3
X_4133_ _7363_/Q _4394_/B _4436_/B1 _7171_/Q VGND VGND VPWR VPWR _4133_/X sky130_fd_sc_hd__a22o_2
XFILLER_110_463 VGND VGND VPWR VPWR sky130_fd_sc_hd__decap_3
XFILLER_68_377 VGND VGND VPWR VPWR sky130_fd_sc_hd__decap_3
XFILLER_95_163 VGND VGND VPWR VPWR sky130_fd_sc_hd__fill_2
X_4064_ _7372_/Q _4435_/B1 _4879_/S _7308_/Q _4063_/X VGND VGND VPWR VPWR _4064_/X
+ sky130_fd_sc_hd__a221o_2
XTAP_TAPCELL_ROW_39_715 VGND VPWR sky130_fd_sc_hd__tapvpwrvgnd_1
XFILLER_83_358 VGND VGND VPWR VPWR sky130_fd_sc_hd__decap_3
XFILLER_24_403 VGND VGND VPWR VPWR sky130_fd_sc_hd__decap_3
XFILLER_36_230 VGND VGND VPWR VPWR sky130_fd_sc_hd__decap_3
XFILLER_36_285 VGND VGND VPWR VPWR sky130_fd_sc_hd__fill_2
XFILLER_51_200 VGND VGND VPWR VPWR sky130_fd_sc_hd__decap_3
XTAP_TAPCELL_ROW_19_483 VGND VPWR sky130_fd_sc_hd__tapvpwrvgnd_1
XFILLER_51_244 VGND VGND VPWR VPWR sky130_fd_sc_hd__decap_3
XFILLER_11_108 VGND VGND VPWR VPWR sky130_fd_sc_hd__decap_3
XFILLER_11_119 VGND VGND VPWR VPWR sky130_fd_sc_hd__decap_3
X_6705_ _7198_/CLK _6705_/D VGND VGND VPWR VPWR _6705_/Q sky130_fd_sc_hd__dfxtp_2
XFILLER_22_15 VGND VGND VPWR VPWR sky130_fd_sc_hd__decap_3
XFILLER_51_299 VGND VGND VPWR VPWR sky130_fd_sc_hd__decap_3
X_4897_ _4896_/A _4896_/B _4896_/Y _4975_/A VGND VGND VPWR VPWR _4897_/X sky130_fd_sc_hd__o211a_2
X_3917_ _6689_/Q _3925_/A2 _3925_/B1 _6867_/Q VGND VGND VPWR VPWR _3917_/X sky130_fd_sc_hd__a22o_2
XFILLER_20_653 VGND VGND VPWR VPWR sky130_fd_sc_hd__decap_3
X_6636_ _6637_/A VGND VGND VPWR VPWR _6636_/Y sky130_fd_sc_hd__inv_2
X_3848_ _6907_/Q _3912_/A2 _3889_/B1 _6851_/Q VGND VGND VPWR VPWR _3848_/X sky130_fd_sc_hd__a22o_2
XFILLER_22_59 VGND VGND VPWR VPWR sky130_fd_sc_hd__decap_3
X_6567_ _6567_/A VGND VGND VPWR VPWR _6567_/Y sky130_fd_sc_hd__inv_2
X_3779_ _6794_/Q _3853_/A2 _3656_/Y _6704_/Q _3778_/X VGND VGND VPWR VPWR _3779_/X
+ sky130_fd_sc_hd__a221o_2
XFILLER_105_202 VGND VGND VPWR VPWR sky130_fd_sc_hd__decap_3
XTAP_TAPCELL_ROW_115_1636 VGND VPWR sky130_fd_sc_hd__tapvpwrvgnd_1
XFILLER_98_19 VGND VGND VPWR VPWR sky130_fd_sc_hd__decap_3
X_6498_ _6635_/A VGND VGND VPWR VPWR _6498_/Y sky130_fd_sc_hd__inv_2
XFILLER_59_311 VGND VGND VPWR VPWR sky130_fd_sc_hd__decap_3
XFILLER_87_620 VGND VGND VPWR VPWR sky130_fd_sc_hd__decap_3
Xoutput494 _5117_/B VGND VGND VPWR VPWR alu_result_out[7] sky130_fd_sc_hd__clkdlybuf4s25_1
Xoutput483 _5656_/A VGND VGND VPWR VPWR alu_result_out[26] sky130_fd_sc_hd__clkdlybuf4s25_1
Xoutput472 _4973_/B VGND VGND VPWR VPWR alu_result_out[16] sky130_fd_sc_hd__clkdlybuf4s25_1
XFILLER_99_491 VGND VGND VPWR VPWR sky130_fd_sc_hd__decap_3
XFILLER_101_430 VGND VGND VPWR VPWR sky130_fd_sc_hd__decap_3
XFILLER_113_290 VGND VGND VPWR VPWR sky130_fd_sc_hd__decap_3
XFILLER_47_12 VGND VGND VPWR VPWR sky130_fd_sc_hd__decap_3
XFILLER_86_130 VGND VGND VPWR VPWR sky130_fd_sc_hd__decap_3
XFILLER_86_141 VGND VGND VPWR VPWR sky130_fd_sc_hd__decap_3
X_7119_ clkload7/A _7119_/D _6399_/Y VGND VGND VPWR VPWR _7119_/Q sky130_fd_sc_hd__dfrtp_2
XFILLER_101_452 VGND VGND VPWR VPWR sky130_fd_sc_hd__decap_3
XFILLER_101_474 VGND VGND VPWR VPWR sky130_fd_sc_hd__fill_2
XFILLER_19_219 VGND VGND VPWR VPWR sky130_fd_sc_hd__decap_3
XFILLER_47_45 VGND VGND VPWR VPWR sky130_fd_sc_hd__decap_3
XFILLER_59_377 VGND VGND VPWR VPWR sky130_fd_sc_hd__decap_3
XFILLER_86_174 VGND VGND VPWR VPWR sky130_fd_sc_hd__decap_3
XFILLER_59_399 VGND VGND VPWR VPWR sky130_fd_sc_hd__decap_3
XFILLER_74_347 VGND VGND VPWR VPWR sky130_fd_sc_hd__decap_3
XFILLER_103_40 VGND VGND VPWR VPWR sky130_fd_sc_hd__decap_3
XFILLER_15_414 VGND VGND VPWR VPWR sky130_fd_sc_hd__decap_3
XFILLER_27_296 VGND VGND VPWR VPWR sky130_fd_sc_hd__decap_3
XFILLER_42_200 VGND VGND VPWR VPWR sky130_fd_sc_hd__decap_3
XFILLER_55_572 VGND VGND VPWR VPWR sky130_fd_sc_hd__decap_3
XFILLER_55_594 VGND VGND VPWR VPWR sky130_fd_sc_hd__decap_3
XFILLER_63_22 VGND VGND VPWR VPWR sky130_fd_sc_hd__decap_3
XFILLER_70_520 VGND VGND VPWR VPWR sky130_fd_sc_hd__decap_3
XFILLER_70_542 VGND VGND VPWR VPWR sky130_fd_sc_hd__decap_3
XFILLER_82_391 VGND VGND VPWR VPWR sky130_fd_sc_hd__decap_3
XFILLER_42_266 VGND VGND VPWR VPWR sky130_fd_sc_hd__fill_2
XFILLER_63_77 VGND VGND VPWR VPWR sky130_fd_sc_hd__decap_3
XFILLER_70_586 VGND VGND VPWR VPWR sky130_fd_sc_hd__fill_2
XFILLER_23_480 VGND VGND VPWR VPWR sky130_fd_sc_hd__decap_3
XFILLER_42_299 VGND VGND VPWR VPWR sky130_fd_sc_hd__decap_3
XFILLER_8_17 VGND VGND VPWR VPWR sky130_fd_sc_hd__decap_3
XFILLER_10_141 VGND VGND VPWR VPWR sky130_fd_sc_hd__decap_3
XFILLER_10_163 VGND VGND VPWR VPWR sky130_fd_sc_hd__decap_3
XFILLER_12_81 VGND VGND VPWR VPWR sky130_fd_sc_hd__decap_3
Xwire577 _6473_/A VGND VGND VPWR VPWR _6606_/A sky130_fd_sc_hd__buf_2
XFILLER_6_178 VGND VGND VPWR VPWR sky130_fd_sc_hd__decap_3
XFILLER_40_9 VGND VGND VPWR VPWR sky130_fd_sc_hd__decap_3
XFILLER_69_108 VGND VGND VPWR VPWR sky130_fd_sc_hd__decap_3
XFILLER_97_417 VGND VGND VPWR VPWR sky130_fd_sc_hd__decap_3
XFILLER_69_119 VGND VGND VPWR VPWR sky130_fd_sc_hd__decap_3
XFILLER_88_85 VGND VGND VPWR VPWR sky130_fd_sc_hd__decap_3
XFILLER_104_290 VGND VGND VPWR VPWR sky130_fd_sc_hd__decap_3
XFILLER_78_631 VGND VGND VPWR VPWR sky130_fd_sc_hd__decap_3
XFILLER_77_141 VGND VGND VPWR VPWR sky130_fd_sc_hd__decap_3
XFILLER_92_100 VGND VGND VPWR VPWR sky130_fd_sc_hd__decap_3
XFILLER_93_623 VGND VGND VPWR VPWR sky130_fd_sc_hd__decap_3
XFILLER_65_325 VGND VGND VPWR VPWR sky130_fd_sc_hd__decap_3
XFILLER_18_230 VGND VGND VPWR VPWR sky130_fd_sc_hd__fill_1
XFILLER_18_241 VGND VGND VPWR VPWR sky130_fd_sc_hd__decap_3
XFILLER_92_144 VGND VGND VPWR VPWR sky130_fd_sc_hd__decap_3
XFILLER_18_274 VGND VGND VPWR VPWR sky130_fd_sc_hd__decap_3
XFILLER_33_211 VGND VGND VPWR VPWR sky130_fd_sc_hd__fill_2
XFILLER_73_380 VGND VGND VPWR VPWR sky130_fd_sc_hd__decap_3
XFILLER_80_339 VGND VGND VPWR VPWR sky130_fd_sc_hd__decap_3
XFILLER_92_188 VGND VGND VPWR VPWR sky130_fd_sc_hd__decap_3
XFILLER_33_222 VGND VGND VPWR VPWR sky130_fd_sc_hd__fill_2
XFILLER_33_244 VGND VGND VPWR VPWR sky130_fd_sc_hd__fill_2
X_4820_ _5156_/S _5634_/B VGND VGND VPWR VPWR _5010_/A sky130_fd_sc_hd__nand2_2
XTAP_TAPCELL_ROW_16_442 VGND VPWR sky130_fd_sc_hd__tapvpwrvgnd_1
XFILLER_33_266 VGND VGND VPWR VPWR sky130_fd_sc_hd__decap_3
XFILLER_61_564 VGND VGND VPWR VPWR sky130_fd_sc_hd__decap_3
XTAP_TAPCELL_ROW_44_784 VGND VPWR sky130_fd_sc_hd__tapvpwrvgnd_1
X_4751_ _4751_/A _4751_/B VGND VGND VPWR VPWR _4751_/Y sky130_fd_sc_hd__nand2_2
X_4682_ _4928_/B _4682_/B _4960_/B VGND VGND VPWR VPWR _4943_/A sky130_fd_sc_hd__and3b_2
X_3702_ _3702_/A1 _3757_/S _3701_/X VGND VGND VPWR VPWR _7401_/D sky130_fd_sc_hd__o21a_2
X_6421_ _6522_/A VGND VGND VPWR VPWR _6421_/Y sky130_fd_sc_hd__inv_2
X_3633_ _3636_/A _5114_/A _5033_/B2 _3630_/A VGND VGND VPWR VPWR _3633_/Y sky130_fd_sc_hd__a22oi_2
XFILLER_108_18 VGND VGND VPWR VPWR sky130_fd_sc_hd__decap_3
XFILLER_108_29 VGND VGND VPWR VPWR sky130_fd_sc_hd__decap_3
X_6352_ _6388_/A VGND VGND VPWR VPWR _6352_/Y sky130_fd_sc_hd__inv_2
X_3564_ _5118_/A _5362_/C VGND VGND VPWR VPWR _3564_/X sky130_fd_sc_hd__and2_2
X_6283_ _6287_/A VGND VGND VPWR VPWR _6283_/Y sky130_fd_sc_hd__inv_2
X_3495_ _7028_/Q _4507_/S _3494_/X VGND VGND VPWR VPWR _3495_/X sky130_fd_sc_hd__a21o_2
XFILLER_102_205 VGND VGND VPWR VPWR sky130_fd_sc_hd__decap_3
XFILLER_69_620 VGND VGND VPWR VPWR sky130_fd_sc_hd__fill_1
X_5234_ _5234_/A0 _4734_/X _5245_/S VGND VGND VPWR VPWR _7213_/D sky130_fd_sc_hd__mux2_2
XFILLER_102_238 VGND VGND VPWR VPWR sky130_fd_sc_hd__decap_3
X_5165_ _5165_/A _5190_/B VGND VGND VPWR VPWR _7245_/D sky130_fd_sc_hd__and2_2
XTAP_TAPCELL_ROW_110_1566 VGND VPWR sky130_fd_sc_hd__tapvpwrvgnd_1
XFILLER_68_141 VGND VGND VPWR VPWR sky130_fd_sc_hd__decap_3
XFILLER_84_601 VGND VGND VPWR VPWR sky130_fd_sc_hd__decap_3
X_4116_ _7076_/Q _4265_/B VGND VGND VPWR VPWR _4117_/C sky130_fd_sc_hd__or2_2
XTAP_TAPCELL_ROW_110_1577 VGND VPWR sky130_fd_sc_hd__tapvpwrvgnd_1
XFILLER_56_336 VGND VGND VPWR VPWR sky130_fd_sc_hd__decap_3
XFILLER_68_185 VGND VGND VPWR VPWR sky130_fd_sc_hd__decap_3
XFILLER_96_483 VGND VGND VPWR VPWR sky130_fd_sc_hd__decap_3
XFILLER_17_15 VGND VGND VPWR VPWR sky130_fd_sc_hd__fill_2
XFILLER_37_561 VGND VGND VPWR VPWR sky130_fd_sc_hd__decap_3
X_4047_ _7245_/Q _4433_/B _4437_/A2 _7027_/Q _4046_/X VGND VGND VPWR VPWR _4047_/X
+ sky130_fd_sc_hd__a221o_2
XFILLER_24_200 VGND VGND VPWR VPWR sky130_fd_sc_hd__decap_3
XFILLER_52_520 VGND VGND VPWR VPWR sky130_fd_sc_hd__decap_3
XFILLER_64_380 VGND VGND VPWR VPWR sky130_fd_sc_hd__decap_3
XTAP_TAPCELL_ROW_65_1034 VGND VPWR sky130_fd_sc_hd__tapvpwrvgnd_1
XFILLER_24_266 VGND VGND VPWR VPWR sky130_fd_sc_hd__decap_3
X_4949_ _4967_/A _4967_/B VGND VGND VPWR VPWR _4949_/Y sky130_fd_sc_hd__nand2_2
XFILLER_20_450 VGND VGND VPWR VPWR sky130_fd_sc_hd__decap_3
X_6619_ _6619_/A VGND VGND VPWR VPWR _6619_/Y sky130_fd_sc_hd__inv_2
XFILLER_106_511 VGND VGND VPWR VPWR sky130_fd_sc_hd__decap_3
XFILLER_106_566 VGND VGND VPWR VPWR sky130_fd_sc_hd__decap_3
XTAP_TAPCELL_ROW_76_1163 VGND VPWR sky130_fd_sc_hd__tapvpwrvgnd_1
XFILLER_79_417 VGND VGND VPWR VPWR sky130_fd_sc_hd__decap_3
XFILLER_58_44 VGND VGND VPWR VPWR sky130_fd_sc_hd__decap_3
XFILLER_58_55 VGND VGND VPWR VPWR sky130_fd_sc_hd__decap_3
XFILLER_94_409 VGND VGND VPWR VPWR sky130_fd_sc_hd__decap_3
XFILLER_58_77 VGND VGND VPWR VPWR sky130_fd_sc_hd__decap_3
XFILLER_75_612 VGND VGND VPWR VPWR sky130_fd_sc_hd__decap_3
XFILLER_101_260 VGND VGND VPWR VPWR sky130_fd_sc_hd__decap_3
XFILLER_47_314 VGND VGND VPWR VPWR sky130_fd_sc_hd__decap_3
XFILLER_59_185 VGND VGND VPWR VPWR sky130_fd_sc_hd__decap_3
XFILLER_75_623 VGND VGND VPWR VPWR sky130_fd_sc_hd__decap_3
XFILLER_114_83 VGND VGND VPWR VPWR sky130_fd_sc_hd__fill_1
XFILLER_114_94 VGND VGND VPWR VPWR sky130_fd_sc_hd__fill_1
XFILLER_62_306 VGND VGND VPWR VPWR sky130_fd_sc_hd__fill_2
XFILLER_74_144 VGND VGND VPWR VPWR sky130_fd_sc_hd__decap_3
XFILLER_74_43 VGND VGND VPWR VPWR sky130_fd_sc_hd__decap_3
XFILLER_75_678 VGND VGND VPWR VPWR sky130_fd_sc_hd__decap_3
XFILLER_43_520 VGND VGND VPWR VPWR sky130_fd_sc_hd__fill_1
XFILLER_62_317 VGND VGND VPWR VPWR sky130_fd_sc_hd__decap_3
XFILLER_74_177 VGND VGND VPWR VPWR sky130_fd_sc_hd__decap_3
XFILLER_90_648 VGND VGND VPWR VPWR sky130_fd_sc_hd__decap_3
XFILLER_55_391 VGND VGND VPWR VPWR sky130_fd_sc_hd__fill_1
XTAP_TAPCELL_ROW_87_1292 VGND VPWR sky130_fd_sc_hd__tapvpwrvgnd_1
XFILLER_15_255 VGND VGND VPWR VPWR sky130_fd_sc_hd__decap_3
XFILLER_70_350 VGND VGND VPWR VPWR sky130_fd_sc_hd__decap_3
XFILLER_90_20 VGND VGND VPWR VPWR sky130_fd_sc_hd__decap_3
XFILLER_70_383 VGND VGND VPWR VPWR sky130_fd_sc_hd__fill_2
XFILLER_70_394 VGND VGND VPWR VPWR sky130_fd_sc_hd__decap_3
XTAP_TAPCELL_ROW_13_412 VGND VPWR sky130_fd_sc_hd__tapvpwrvgnd_1
XFILLER_90_97 VGND VGND VPWR VPWR sky130_fd_sc_hd__decap_3
XTAP_TAPCELL_ROW_41_743 VGND VPWR sky130_fd_sc_hd__tapvpwrvgnd_1
XFILLER_11_472 VGND VGND VPWR VPWR sky130_fd_sc_hd__decap_3
XFILLER_109_382 VGND VGND VPWR VPWR sky130_fd_sc_hd__decap_3
XFILLER_109_393 VGND VGND VPWR VPWR sky130_fd_sc_hd__decap_3
XFILLER_112_525 VGND VGND VPWR VPWR sky130_fd_sc_hd__decap_3
XFILLER_97_203 VGND VGND VPWR VPWR sky130_fd_sc_hd__decap_3
XFILLER_97_225 VGND VGND VPWR VPWR sky130_fd_sc_hd__decap_3
XFILLER_112_536 VGND VGND VPWR VPWR sky130_fd_sc_hd__decap_3
XFILLER_112_558 VGND VGND VPWR VPWR sky130_fd_sc_hd__decap_3
XFILLER_2_192 VGND VGND VPWR VPWR sky130_fd_sc_hd__decap_3
XFILLER_97_258 VGND VGND VPWR VPWR sky130_fd_sc_hd__decap_3
XFILLER_78_461 VGND VGND VPWR VPWR sky130_fd_sc_hd__decap_3
XFILLER_17_3 VGND VGND VPWR VPWR sky130_fd_sc_hd__decap_3
XFILLER_65_122 VGND VGND VPWR VPWR sky130_fd_sc_hd__decap_3
XFILLER_66_623 VGND VGND VPWR VPWR sky130_fd_sc_hd__fill_1
XFILLER_66_645 VGND VGND VPWR VPWR sky130_fd_sc_hd__fill_1
XFILLER_93_420 VGND VGND VPWR VPWR sky130_fd_sc_hd__decap_3
Xsingle_cycle_cpu_584 VGND VGND VPWR VPWR single_cycle_cpu_584/HI instruction_out[31]
+ sky130_fd_sc_hd__conb_1
XTAP_TAPCELL_ROW_49_843 VGND VPWR sky130_fd_sc_hd__tapvpwrvgnd_1
XFILLER_38_347 VGND VGND VPWR VPWR sky130_fd_sc_hd__decap_3
XFILLER_65_133 VGND VGND VPWR VPWR sky130_fd_sc_hd__decap_3
XFILLER_81_615 VGND VGND VPWR VPWR sky130_fd_sc_hd__fill_1
X_6970_ _6972_/CLK _6970_/D VGND VGND VPWR VPWR _6970_/Q sky130_fd_sc_hd__dfxtp_2
XFILLER_19_561 VGND VGND VPWR VPWR sky130_fd_sc_hd__fill_1
XFILLER_53_317 VGND VGND VPWR VPWR sky130_fd_sc_hd__decap_3
XFILLER_65_199 VGND VGND VPWR VPWR sky130_fd_sc_hd__decap_3
XFILLER_81_626 VGND VGND VPWR VPWR sky130_fd_sc_hd__decap_3
XFILLER_0_95 VGND VGND VPWR VPWR sky130_fd_sc_hd__decap_3
XFILLER_46_380 VGND VGND VPWR VPWR sky130_fd_sc_hd__decap_3
XFILLER_80_147 VGND VGND VPWR VPWR sky130_fd_sc_hd__decap_3
XFILLER_34_586 VGND VGND VPWR VPWR sky130_fd_sc_hd__fill_2
XFILLER_61_361 VGND VGND VPWR VPWR sky130_fd_sc_hd__decap_3
XFILLER_21_225 VGND VGND VPWR VPWR sky130_fd_sc_hd__decap_3
X_4803_ _7003_/Q _4802_/X _4677_/B _5129_/B VGND VGND VPWR VPWR _4804_/B sky130_fd_sc_hd__o211ai_2
XFILLER_21_258 VGND VGND VPWR VPWR sky130_fd_sc_hd__decap_3
X_4734_ _4726_/X _4729_/Y _7007_/D _4836_/S VGND VGND VPWR VPWR _4734_/X sky130_fd_sc_hd__o22a_2
XFILLER_107_319 VGND VGND VPWR VPWR sky130_fd_sc_hd__decap_3
X_4665_ _7005_/Q _5605_/B VGND VGND VPWR VPWR _4665_/X sky130_fd_sc_hd__or2_2
X_7384_ _7384_/CLK _7384_/D _6664_/Y VGND VGND VPWR VPWR _7384_/Q sky130_fd_sc_hd__dfrtp_2
Xhold900 _7075_/Q VGND VGND VPWR VPWR _7075_/D sky130_fd_sc_hd__dlygate4sd3_1
Xhold911 _6702_/Q VGND VGND VPWR VPWR hold911/X sky130_fd_sc_hd__dlygate4sd3_1
Xhold922 _6706_/Q VGND VGND VPWR VPWR hold922/X sky130_fd_sc_hd__dlygate4sd3_1
X_6404_ _6567_/A VGND VGND VPWR VPWR _6404_/Y sky130_fd_sc_hd__inv_2
X_3616_ _4614_/C _3616_/B VGND VGND VPWR VPWR _3616_/Y sky130_fd_sc_hd__nand2_2
XFILLER_115_341 VGND VGND VPWR VPWR sky130_fd_sc_hd__decap_3
Xhold933 _6709_/Q VGND VGND VPWR VPWR hold933/X sky130_fd_sc_hd__dlygate4sd3_1
Xhold955 _7031_/Q VGND VGND VPWR VPWR _5593_/A sky130_fd_sc_hd__dlygate4sd3_1
Xhold944 _7021_/Q VGND VGND VPWR VPWR _5613_/A sky130_fd_sc_hd__dlygate4sd3_1
X_6335_ _6568_/A VGND VGND VPWR VPWR _6335_/Y sky130_fd_sc_hd__inv_2
X_3547_ _3547_/A _3547_/B VGND VGND VPWR VPWR _3547_/Y sky130_fd_sc_hd__nand2_2
XFILLER_103_514 VGND VGND VPWR VPWR sky130_fd_sc_hd__decap_3
XFILLER_88_214 VGND VGND VPWR VPWR sky130_fd_sc_hd__decap_3
Xhold988 _7047_/Q VGND VGND VPWR VPWR hold988/X sky130_fd_sc_hd__dlygate4sd3_1
Xhold977 _7035_/Q VGND VGND VPWR VPWR hold977/X sky130_fd_sc_hd__dlygate4sd3_1
Xhold966 _7022_/Q VGND VGND VPWR VPWR _5611_/A sky130_fd_sc_hd__dlygate4sd3_1
XFILLER_103_558 VGND VGND VPWR VPWR sky130_fd_sc_hd__fill_2
XFILLER_88_247 VGND VGND VPWR VPWR sky130_fd_sc_hd__decap_3
Xhold999 _7257_/Q VGND VGND VPWR VPWR hold999/X sky130_fd_sc_hd__dlygate4sd3_1
X_6266_ _6522_/A VGND VGND VPWR VPWR _6266_/Y sky130_fd_sc_hd__inv_2
X_3478_ _7216_/Q _3318_/B _4534_/S _7029_/Q _3477_/X VGND VGND VPWR VPWR _3478_/X
+ sky130_fd_sc_hd__a221o_2
XFILLER_69_461 VGND VGND VPWR VPWR sky130_fd_sc_hd__decap_3
X_5217_ _5217_/A _5217_/B VGND VGND VPWR VPWR _7220_/D sky130_fd_sc_hd__and2_2
XFILLER_28_47 VGND VGND VPWR VPWR sky130_fd_sc_hd__decap_3
XFILLER_56_122 VGND VGND VPWR VPWR sky130_fd_sc_hd__decap_3
XFILLER_96_280 VGND VGND VPWR VPWR sky130_fd_sc_hd__decap_3
X_5148_ _5144_/A _5071_/A _3618_/C _3540_/X VGND VGND VPWR VPWR _5148_/X sky130_fd_sc_hd__a211o_2
XFILLER_28_69 VGND VGND VPWR VPWR sky130_fd_sc_hd__decap_3
XFILLER_84_453 VGND VGND VPWR VPWR sky130_fd_sc_hd__decap_3
X_5079_ _5156_/S _6987_/D _5078_/X VGND VGND VPWR VPWR _5079_/X sky130_fd_sc_hd__o21a_2
XFILLER_44_306 VGND VGND VPWR VPWR sky130_fd_sc_hd__fill_2
XFILLER_44_339 VGND VGND VPWR VPWR sky130_fd_sc_hd__decap_3
XFILLER_56_177 VGND VGND VPWR VPWR sky130_fd_sc_hd__decap_3
XFILLER_71_103 VGND VGND VPWR VPWR sky130_fd_sc_hd__decap_3
XFILLER_84_486 VGND VGND VPWR VPWR sky130_fd_sc_hd__decap_3
XFILLER_37_380 VGND VGND VPWR VPWR sky130_fd_sc_hd__decap_3
XFILLER_44_35 VGND VGND VPWR VPWR sky130_fd_sc_hd__decap_3
XFILLER_12_203 VGND VGND VPWR VPWR sky130_fd_sc_hd__decap_3
XFILLER_40_501 VGND VGND VPWR VPWR sky130_fd_sc_hd__decap_3
XFILLER_71_169 VGND VGND VPWR VPWR sky130_fd_sc_hd__decap_3
XFILLER_44_79 VGND VGND VPWR VPWR sky130_fd_sc_hd__decap_3
XFILLER_100_41 VGND VGND VPWR VPWR sky130_fd_sc_hd__decap_3
XFILLER_100_85 VGND VGND VPWR VPWR sky130_fd_sc_hd__decap_3
XFILLER_8_229 VGND VGND VPWR VPWR sky130_fd_sc_hd__decap_3
XFILLER_60_67 VGND VGND VPWR VPWR sky130_fd_sc_hd__decap_3
XFILLER_106_330 VGND VGND VPWR VPWR sky130_fd_sc_hd__decap_3
XFILLER_109_72 VGND VGND VPWR VPWR sky130_fd_sc_hd__decap_3
XFILLER_109_83 VGND VGND VPWR VPWR sky130_fd_sc_hd__decap_3
XFILLER_4_446 VGND VGND VPWR VPWR sky130_fd_sc_hd__decap_3
XFILLER_69_21 VGND VGND VPWR VPWR sky130_fd_sc_hd__decap_3
XFILLER_106_374 VGND VGND VPWR VPWR sky130_fd_sc_hd__decap_3
XFILLER_69_43 VGND VGND VPWR VPWR sky130_fd_sc_hd__decap_3
XFILLER_69_87 VGND VGND VPWR VPWR sky130_fd_sc_hd__decap_3
XFILLER_79_225 VGND VGND VPWR VPWR sky130_fd_sc_hd__decap_3
XFILLER_0_641 VGND VGND VPWR VPWR sky130_fd_sc_hd__decap_3
XFILLER_94_206 VGND VGND VPWR VPWR sky130_fd_sc_hd__decap_3
XFILLER_48_634 VGND VGND VPWR VPWR sky130_fd_sc_hd__fill_2
XFILLER_85_20 VGND VGND VPWR VPWR sky130_fd_sc_hd__decap_3
XFILLER_85_42 VGND VGND VPWR VPWR sky130_fd_sc_hd__decap_3
XTAP_TAPCELL_ROW_89_1321 VGND VPWR sky130_fd_sc_hd__tapvpwrvgnd_1
XFILLER_47_155 VGND VGND VPWR VPWR sky130_fd_sc_hd__decap_3
XFILLER_75_442 VGND VGND VPWR VPWR sky130_fd_sc_hd__decap_3
XFILLER_75_464 VGND VGND VPWR VPWR sky130_fd_sc_hd__decap_3
XFILLER_85_75 VGND VGND VPWR VPWR sky130_fd_sc_hd__decap_3
XFILLER_62_114 VGND VGND VPWR VPWR sky130_fd_sc_hd__decap_3
XFILLER_63_615 VGND VGND VPWR VPWR sky130_fd_sc_hd__fill_1
XFILLER_75_497 VGND VGND VPWR VPWR sky130_fd_sc_hd__decap_3
XTAP_TAPCELL_ROW_46_802 VGND VPWR sky130_fd_sc_hd__tapvpwrvgnd_1
XFILLER_18_91 VGND VGND VPWR VPWR sky130_fd_sc_hd__decap_3
XFILLER_47_199 VGND VGND VPWR VPWR sky130_fd_sc_hd__decap_3
XFILLER_62_125 VGND VGND VPWR VPWR sky130_fd_sc_hd__decap_3
XFILLER_90_434 VGND VGND VPWR VPWR sky130_fd_sc_hd__decap_3
XFILLER_50_309 VGND VGND VPWR VPWR sky130_fd_sc_hd__decap_3
XFILLER_62_169 VGND VGND VPWR VPWR sky130_fd_sc_hd__decap_3
XFILLER_90_467 VGND VGND VPWR VPWR sky130_fd_sc_hd__decap_3
XFILLER_43_383 VGND VGND VPWR VPWR sky130_fd_sc_hd__decap_3
XFILLER_31_567 VGND VGND VPWR VPWR sky130_fd_sc_hd__fill_2
XFILLER_116_116 VGND VGND VPWR VPWR sky130_fd_sc_hd__decap_3
XFILLER_7_262 VGND VGND VPWR VPWR sky130_fd_sc_hd__decap_3
XFILLER_7_284 VGND VGND VPWR VPWR sky130_fd_sc_hd__decap_3
X_4450_ _4451_/A _4451_/B VGND VGND VPWR VPWR _4452_/A sky130_fd_sc_hd__and2_2
X_4381_ _4381_/A _4381_/B VGND VGND VPWR VPWR _4967_/B sky130_fd_sc_hd__nand2_2
X_3401_ _4467_/A _3519_/B _5294_/A _3330_/Y VGND VGND VPWR VPWR _3401_/X sky130_fd_sc_hd__a31o_4
X_3332_ _4467_/A _3332_/B VGND VGND VPWR VPWR _3341_/A sky130_fd_sc_hd__nand2_2
XFILLER_98_501 VGND VGND VPWR VPWR sky130_fd_sc_hd__decap_3
XFILLER_112_344 VGND VGND VPWR VPWR sky130_fd_sc_hd__decap_3
XFILLER_98_545 VGND VGND VPWR VPWR sky130_fd_sc_hd__decap_3
XFILLER_100_506 VGND VGND VPWR VPWR sky130_fd_sc_hd__decap_3
XFILLER_112_377 VGND VGND VPWR VPWR sky130_fd_sc_hd__decap_3
XFILLER_58_409 VGND VGND VPWR VPWR sky130_fd_sc_hd__decap_3
XFILLER_85_206 VGND VGND VPWR VPWR sky130_fd_sc_hd__decap_3
XFILLER_98_589 VGND VGND VPWR VPWR sky130_fd_sc_hd__fill_2
XFILLER_98_578 VGND VGND VPWR VPWR sky130_fd_sc_hd__decap_3
XFILLER_38_100 VGND VGND VPWR VPWR sky130_fd_sc_hd__decap_3
X_5002_ _5003_/A _5003_/B _3548_/X VGND VGND VPWR VPWR _5002_/Y sky130_fd_sc_hd__a21oi_2
XFILLER_38_133 VGND VGND VPWR VPWR sky130_fd_sc_hd__decap_3
XFILLER_38_144 VGND VGND VPWR VPWR sky130_fd_sc_hd__decap_3
XFILLER_66_442 VGND VGND VPWR VPWR sky130_fd_sc_hd__decap_3
XFILLER_38_177 VGND VGND VPWR VPWR sky130_fd_sc_hd__decap_3
XFILLER_54_637 VGND VGND VPWR VPWR sky130_fd_sc_hd__decap_3
XFILLER_93_250 VGND VGND VPWR VPWR sky130_fd_sc_hd__decap_3
XFILLER_53_136 VGND VGND VPWR VPWR sky130_fd_sc_hd__decap_3
XFILLER_81_434 VGND VGND VPWR VPWR sky130_fd_sc_hd__decap_3
X_6953_ _6965_/CLK _6953_/D VGND VGND VPWR VPWR _6953_/Q sky130_fd_sc_hd__dfxtp_2
XFILLER_53_158 VGND VGND VPWR VPWR sky130_fd_sc_hd__decap_3
XFILLER_53_169 VGND VGND VPWR VPWR sky130_fd_sc_hd__decap_3
XFILLER_62_670 VGND VGND VPWR VPWR sky130_fd_sc_hd__fill_1
XFILLER_81_467 VGND VGND VPWR VPWR sky130_fd_sc_hd__decap_3
Xclkbuf_3_5__f_clk clkbuf_0_clk/X VGND VGND VPWR VPWR clkbuf_leaf_7_clk/A sky130_fd_sc_hd__clkbuf_16
X_6884_ _7390_/CLK _6884_/D VGND VGND VPWR VPWR _6884_/Q sky130_fd_sc_hd__dfxtp_2
XFILLER_14_38 VGND VGND VPWR VPWR sky130_fd_sc_hd__decap_3
X_5697_ _7354_/Q hold918/X _5706_/S VGND VGND VPWR VPWR _6698_/D sky130_fd_sc_hd__mux2_2
XFILLER_107_116 VGND VGND VPWR VPWR sky130_fd_sc_hd__decap_3
X_4648_ _4648_/A VGND VGND VPWR VPWR _4648_/Y sky130_fd_sc_hd__inv_2
Xhold730 _6859_/Q VGND VGND VPWR VPWR _6859_/D sky130_fd_sc_hd__dlygate4sd3_1
XFILLER_116_661 VGND VGND VPWR VPWR sky130_fd_sc_hd__fill_1
X_7367_ _7371_/CLK _7367_/D _6647_/Y VGND VGND VPWR VPWR _7367_/Q sky130_fd_sc_hd__dfrtp_2
Xhold741 _6902_/Q VGND VGND VPWR VPWR _6902_/D sky130_fd_sc_hd__dlygate4sd3_1
Xhold752 _6734_/Q VGND VGND VPWR VPWR _6734_/D sky130_fd_sc_hd__dlygate4sd3_1
Xhold763 _6966_/Q VGND VGND VPWR VPWR _6966_/D sky130_fd_sc_hd__dlygate4sd3_1
X_4579_ _7291_/Q _4595_/B VGND VGND VPWR VPWR _7291_/D sky130_fd_sc_hd__and2_2
XTAP_TAPCELL_ROW_73_1122 VGND VPWR sky130_fd_sc_hd__tapvpwrvgnd_1
XFILLER_103_311 VGND VGND VPWR VPWR sky130_fd_sc_hd__decap_3
XFILLER_1_449 VGND VGND VPWR VPWR sky130_fd_sc_hd__decap_3
XFILLER_39_13 VGND VGND VPWR VPWR sky130_fd_sc_hd__decap_3
X_7298_ _7330_/CLK _7298_/D _6578_/Y VGND VGND VPWR VPWR _7298_/Q sky130_fd_sc_hd__dfrtp_2
Xhold774 _6783_/Q VGND VGND VPWR VPWR _6783_/D sky130_fd_sc_hd__dlygate4sd3_1
Xhold785 _6779_/Q VGND VGND VPWR VPWR _6779_/D sky130_fd_sc_hd__dlygate4sd3_1
Xhold796 _6972_/Q VGND VGND VPWR VPWR _6972_/D sky130_fd_sc_hd__dlygate4sd3_1
X_6318_ _6674_/A VGND VGND VPWR VPWR _6318_/Y sky130_fd_sc_hd__inv_2
XTAP_TAPCELL_ROW_73_1133 VGND VPWR sky130_fd_sc_hd__tapvpwrvgnd_1
XFILLER_103_355 VGND VGND VPWR VPWR sky130_fd_sc_hd__decap_3
XFILLER_39_57 VGND VGND VPWR VPWR sky130_fd_sc_hd__decap_3
XFILLER_103_388 VGND VGND VPWR VPWR sky130_fd_sc_hd__decap_3
XFILLER_29_111 VGND VGND VPWR VPWR sky130_fd_sc_hd__fill_1
XFILLER_57_420 VGND VGND VPWR VPWR sky130_fd_sc_hd__fill_1
XFILLER_76_217 VGND VGND VPWR VPWR sky130_fd_sc_hd__decap_3
XFILLER_29_122 VGND VGND VPWR VPWR sky130_fd_sc_hd__decap_3
XFILLER_57_442 VGND VGND VPWR VPWR sky130_fd_sc_hd__decap_3
XFILLER_29_155 VGND VGND VPWR VPWR sky130_fd_sc_hd__decap_3
XFILLER_45_615 VGND VGND VPWR VPWR sky130_fd_sc_hd__fill_1
XFILLER_55_34 VGND VGND VPWR VPWR sky130_fd_sc_hd__decap_3
XFILLER_57_464 VGND VGND VPWR VPWR sky130_fd_sc_hd__fill_1
XFILLER_57_486 VGND VGND VPWR VPWR sky130_fd_sc_hd__decap_3
XFILLER_72_401 VGND VGND VPWR VPWR sky130_fd_sc_hd__decap_3
XFILLER_84_261 VGND VGND VPWR VPWR sky130_fd_sc_hd__decap_3
XTAP_TAPCELL_ROW_4_298 VGND VPWR sky130_fd_sc_hd__tapvpwrvgnd_1
XFILLER_29_199 VGND VGND VPWR VPWR sky130_fd_sc_hd__decap_3
XFILLER_44_125 VGND VGND VPWR VPWR sky130_fd_sc_hd__decap_3
XFILLER_55_45 VGND VGND VPWR VPWR sky130_fd_sc_hd__decap_3
XFILLER_72_445 VGND VGND VPWR VPWR sky130_fd_sc_hd__decap_3
XFILLER_84_294 VGND VGND VPWR VPWR sky130_fd_sc_hd__decap_3
XFILLER_111_40 VGND VGND VPWR VPWR sky130_fd_sc_hd__decap_3
XFILLER_13_501 VGND VGND VPWR VPWR sky130_fd_sc_hd__decap_3
XFILLER_25_361 VGND VGND VPWR VPWR sky130_fd_sc_hd__decap_3
XFILLER_44_169 VGND VGND VPWR VPWR sky130_fd_sc_hd__decap_3
XFILLER_53_670 VGND VGND VPWR VPWR sky130_fd_sc_hd__fill_2
XFILLER_55_89 VGND VGND VPWR VPWR sky130_fd_sc_hd__fill_2
XFILLER_52_180 VGND VGND VPWR VPWR sky130_fd_sc_hd__fill_2
XFILLER_53_681 VGND VGND VPWR VPWR sky130_fd_sc_hd__fill_1
XFILLER_71_22 VGND VGND VPWR VPWR sky130_fd_sc_hd__decap_3
XTAP_TAPCELL_ROW_84_1262 VGND VPWR sky130_fd_sc_hd__tapvpwrvgnd_1
XFILLER_40_342 VGND VGND VPWR VPWR sky130_fd_sc_hd__decap_3
XFILLER_71_44 VGND VGND VPWR VPWR sky130_fd_sc_hd__decap_3
XFILLER_9_505 VGND VGND VPWR VPWR sky130_fd_sc_hd__fill_1
XFILLER_71_66 VGND VGND VPWR VPWR sky130_fd_sc_hd__decap_3
XTAP_TAPCELL_ROW_51_860 VGND VPWR sky130_fd_sc_hd__tapvpwrvgnd_1
XFILLER_107_650 VGND VGND VPWR VPWR sky130_fd_sc_hd__decap_3
XFILLER_113_119 VGND VGND VPWR VPWR sky130_fd_sc_hd__decap_3
XFILLER_4_276 VGND VGND VPWR VPWR sky130_fd_sc_hd__decap_3
XTAP_TAPCELL_ROW_95_1391 VGND VPWR sky130_fd_sc_hd__tapvpwrvgnd_1
XFILLER_106_171 VGND VGND VPWR VPWR sky130_fd_sc_hd__decap_3
XFILLER_67_228 VGND VGND VPWR VPWR sky130_fd_sc_hd__decap_3
XFILLER_95_526 VGND VGND VPWR VPWR sky130_fd_sc_hd__decap_3
XFILLER_96_74 VGND VGND VPWR VPWR sky130_fd_sc_hd__decap_3
XFILLER_96_85 VGND VGND VPWR VPWR sky130_fd_sc_hd__fill_2
XFILLER_0_493 VGND VGND VPWR VPWR sky130_fd_sc_hd__fill_1
XFILLER_48_442 VGND VGND VPWR VPWR sky130_fd_sc_hd__decap_3
XFILLER_95_559 VGND VGND VPWR VPWR sky130_fd_sc_hd__fill_1
XFILLER_29_90 VGND VGND VPWR VPWR sky130_fd_sc_hd__decap_3
XFILLER_75_272 VGND VGND VPWR VPWR sky130_fd_sc_hd__decap_3
XFILLER_82_209 VGND VGND VPWR VPWR sky130_fd_sc_hd__decap_3
XTAP_TAPCELL_ROW_59_960 VGND VPWR sky130_fd_sc_hd__tapvpwrvgnd_1
XFILLER_63_423 VGND VGND VPWR VPWR sky130_fd_sc_hd__decap_3
XFILLER_75_294 VGND VGND VPWR VPWR sky130_fd_sc_hd__decap_3
XFILLER_90_231 VGND VGND VPWR VPWR sky130_fd_sc_hd__decap_3
Xplace401 _3560_/Y VGND VGND VPWR VPWR _3562_/B sky130_fd_sc_hd__buf_2
Xplace412 _4505_/S VGND VGND VPWR VPWR _4486_/S sky130_fd_sc_hd__buf_2
Xplace423 _4414_/B1 VGND VGND VPWR VPWR _3964_/S sky130_fd_sc_hd__buf_2
Xplace434 _3371_/Y VGND VGND VPWR VPWR _4414_/B1 sky130_fd_sc_hd__buf_2
Xplace445 _4664_/A VGND VGND VPWR VPWR _4975_/A sky130_fd_sc_hd__buf_2
Xplace456 _6983_/Q VGND VGND VPWR VPWR _3561_/B sky130_fd_sc_hd__buf_2
XFILLER_16_361 VGND VGND VPWR VPWR sky130_fd_sc_hd__decap_3
XFILLER_90_286 VGND VGND VPWR VPWR sky130_fd_sc_hd__decap_3
X_3881_ _6724_/Q _3892_/A2 _3881_/B1 _6719_/Q VGND VGND VPWR VPWR _3881_/X sky130_fd_sc_hd__a22o_2
XFILLER_84_3 VGND VGND VPWR VPWR sky130_fd_sc_hd__decap_3
XFILLER_6_61 VGND VGND VPWR VPWR sky130_fd_sc_hd__decap_3
X_7221_ clkload2/A _7221_/D _6501_/Y VGND VGND VPWR VPWR _7221_/Q sky130_fd_sc_hd__dfrtp_2
X_4433_ _7239_/Q _4433_/B VGND VGND VPWR VPWR _4433_/X sky130_fd_sc_hd__and2_2
XFILLER_116_29 VGND VGND VPWR VPWR sky130_fd_sc_hd__decap_3
X_7152_ clkload7/A _7152_/D _6432_/Y VGND VGND VPWR VPWR _7152_/Q sky130_fd_sc_hd__dfrtp_2
X_4364_ _4364_/A _4364_/B VGND VGND VPWR VPWR _4364_/Y sky130_fd_sc_hd__nor2_2
XFILLER_112_141 VGND VGND VPWR VPWR sky130_fd_sc_hd__fill_1
XFILLER_58_206 VGND VGND VPWR VPWR sky130_fd_sc_hd__decap_3
X_7083_ _7330_/CLK _7083_/D _6363_/Y VGND VGND VPWR VPWR _7083_/Q sky130_fd_sc_hd__dfrtp_2
X_4295_ _3607_/B _4295_/B VGND VGND VPWR VPWR _4295_/X sky130_fd_sc_hd__and2b_2
XFILLER_39_420 VGND VGND VPWR VPWR sky130_fd_sc_hd__decap_3
XFILLER_58_239 VGND VGND VPWR VPWR sky130_fd_sc_hd__decap_3
XFILLER_98_386 VGND VGND VPWR VPWR sky130_fd_sc_hd__decap_3
XFILLER_39_442 VGND VGND VPWR VPWR sky130_fd_sc_hd__decap_3
XFILLER_54_412 VGND VGND VPWR VPWR sky130_fd_sc_hd__decap_3
XFILLER_26_136 VGND VGND VPWR VPWR sky130_fd_sc_hd__decap_3
XFILLER_54_445 VGND VGND VPWR VPWR sky130_fd_sc_hd__decap_3
XFILLER_94_592 VGND VGND VPWR VPWR sky130_fd_sc_hd__fill_2
XTAP_TAPCELL_ROW_107_1538 VGND VPWR sky130_fd_sc_hd__tapvpwrvgnd_1
XFILLER_54_456 VGND VGND VPWR VPWR sky130_fd_sc_hd__decap_3
X_6936_ _6936_/CLK _6936_/D VGND VGND VPWR VPWR _6936_/Q sky130_fd_sc_hd__dfxtp_2
XTAP_TAPCELL_ROW_1_268 VGND VPWR sky130_fd_sc_hd__tapvpwrvgnd_1
XFILLER_25_48 VGND VGND VPWR VPWR sky130_fd_sc_hd__decap_3
XFILLER_35_670 VGND VGND VPWR VPWR sky130_fd_sc_hd__fill_2
XFILLER_41_128 VGND VGND VPWR VPWR sky130_fd_sc_hd__decap_3
XTAP_TAPCELL_ROW_37_698 VGND VPWR sky130_fd_sc_hd__tapvpwrvgnd_1
XFILLER_22_342 VGND VGND VPWR VPWR sky130_fd_sc_hd__decap_3
XFILLER_34_191 VGND VGND VPWR VPWR sky130_fd_sc_hd__decap_3
X_6867_ _7381_/CLK _6867_/D VGND VGND VPWR VPWR _6867_/Q sky130_fd_sc_hd__dfxtp_2
XFILLER_22_386 VGND VGND VPWR VPWR sky130_fd_sc_hd__decap_3
XFILLER_41_14 VGND VGND VPWR VPWR sky130_fd_sc_hd__decap_3
X_6798_ _7406_/CLK _6798_/D VGND VGND VPWR VPWR _6798_/Q sky130_fd_sc_hd__dfxtp_2
XFILLER_41_36 VGND VGND VPWR VPWR sky130_fd_sc_hd__decap_3
XFILLER_41_69 VGND VGND VPWR VPWR sky130_fd_sc_hd__decap_3
XFILLER_104_631 VGND VGND VPWR VPWR sky130_fd_sc_hd__fill_1
XFILLER_116_480 VGND VGND VPWR VPWR sky130_fd_sc_hd__decap_3
XFILLER_1_202 VGND VGND VPWR VPWR sky130_fd_sc_hd__decap_3
XFILLER_89_331 VGND VGND VPWR VPWR sky130_fd_sc_hd__decap_3
XTAP_TAPCELL_ROW_9_357 VGND VPWR sky130_fd_sc_hd__tapvpwrvgnd_1
XFILLER_103_141 VGND VGND VPWR VPWR sky130_fd_sc_hd__decap_3
XFILLER_104_653 VGND VGND VPWR VPWR sky130_fd_sc_hd__decap_3
XFILLER_1_246 VGND VGND VPWR VPWR sky130_fd_sc_hd__decap_3
Xhold593 _6808_/Q VGND VGND VPWR VPWR _6808_/D sky130_fd_sc_hd__dlygate4sd3_1
XFILLER_49_206 VGND VGND VPWR VPWR sky130_fd_sc_hd__fill_2
XFILLER_49_228 VGND VGND VPWR VPWR sky130_fd_sc_hd__decap_3
XFILLER_77_526 VGND VGND VPWR VPWR sky130_fd_sc_hd__decap_3
XFILLER_103_196 VGND VGND VPWR VPWR sky130_fd_sc_hd__decap_3
XFILLER_66_44 VGND VGND VPWR VPWR sky130_fd_sc_hd__decap_3
XFILLER_92_507 VGND VGND VPWR VPWR sky130_fd_sc_hd__decap_3
XFILLER_57_261 VGND VGND VPWR VPWR sky130_fd_sc_hd__decap_3
XFILLER_57_272 VGND VGND VPWR VPWR sky130_fd_sc_hd__decap_3
XFILLER_66_77 VGND VGND VPWR VPWR sky130_fd_sc_hd__fill_1
XFILLER_17_125 VGND VGND VPWR VPWR sky130_fd_sc_hd__decap_3
XFILLER_18_637 VGND VGND VPWR VPWR sky130_fd_sc_hd__decap_3
XFILLER_45_423 VGND VGND VPWR VPWR sky130_fd_sc_hd__fill_1
XFILLER_45_445 VGND VGND VPWR VPWR sky130_fd_sc_hd__decap_3
XFILLER_72_231 VGND VGND VPWR VPWR sky130_fd_sc_hd__decap_3
XFILLER_45_467 VGND VGND VPWR VPWR sky130_fd_sc_hd__decap_3
XFILLER_72_253 VGND VGND VPWR VPWR sky130_fd_sc_hd__decap_3
XFILLER_82_32 VGND VGND VPWR VPWR sky130_fd_sc_hd__decap_3
XFILLER_60_415 VGND VGND VPWR VPWR sky130_fd_sc_hd__decap_3
XFILLER_72_286 VGND VGND VPWR VPWR sky130_fd_sc_hd__decap_3
XFILLER_82_65 VGND VGND VPWR VPWR sky130_fd_sc_hd__fill_1
XFILLER_32_139 VGND VGND VPWR VPWR sky130_fd_sc_hd__fill_1
XFILLER_60_448 VGND VGND VPWR VPWR sky130_fd_sc_hd__decap_3
XFILLER_82_76 VGND VGND VPWR VPWR sky130_fd_sc_hd__decap_3
XFILLER_40_150 VGND VGND VPWR VPWR sky130_fd_sc_hd__decap_3
XFILLER_41_673 VGND VGND VPWR VPWR sky130_fd_sc_hd__fill_2
XFILLER_40_183 VGND VGND VPWR VPWR sky130_fd_sc_hd__decap_3
XFILLER_9_346 VGND VGND VPWR VPWR sky130_fd_sc_hd__decap_3
XTAP_TAPCELL_ROW_97_1420 VGND VPWR sky130_fd_sc_hd__tapvpwrvgnd_1
XFILLER_9_379 VGND VGND VPWR VPWR sky130_fd_sc_hd__decap_3
XFILLER_5_541 VGND VGND VPWR VPWR sky130_fd_sc_hd__fill_2
XFILLER_114_406 VGND VGND VPWR VPWR sky130_fd_sc_hd__decap_3
XFILLER_68_548 VGND VGND VPWR VPWR sky130_fd_sc_hd__decap_3
XFILLER_95_301 VGND VGND VPWR VPWR sky130_fd_sc_hd__decap_3
XFILLER_95_312 VGND VGND VPWR VPWR sky130_fd_sc_hd__decap_3
X_4080_ _4075_/X _4079_/X _4425_/A VGND VGND VPWR VPWR _4451_/B sky130_fd_sc_hd__o21ai_2
XFILLER_110_689 VGND VGND VPWR VPWR sky130_fd_sc_hd__decap_3
XFILLER_36_401 VGND VGND VPWR VPWR sky130_fd_sc_hd__fill_2
XFILLER_48_250 VGND VGND VPWR VPWR sky130_fd_sc_hd__fill_2
XFILLER_76_570 VGND VGND VPWR VPWR sky130_fd_sc_hd__decap_3
XFILLER_83_529 VGND VGND VPWR VPWR sky130_fd_sc_hd__decap_3
XFILLER_95_378 VGND VGND VPWR VPWR sky130_fd_sc_hd__decap_3
XFILLER_48_294 VGND VGND VPWR VPWR sky130_fd_sc_hd__decap_3
XFILLER_91_551 VGND VGND VPWR VPWR sky130_fd_sc_hd__decap_3
XFILLER_91_573 VGND VGND VPWR VPWR sky130_fd_sc_hd__decap_3
XFILLER_23_128 VGND VGND VPWR VPWR sky130_fd_sc_hd__fill_2
XFILLER_63_275 VGND VGND VPWR VPWR sky130_fd_sc_hd__decap_3
Xplace264 _4769_/X VGND VGND VPWR VPWR _5663_/A sky130_fd_sc_hd__buf_2
X_4982_ _6992_/Q _4982_/B _5009_/A VGND VGND VPWR VPWR _4983_/C sky130_fd_sc_hd__or3_2
XFILLER_16_180 VGND VGND VPWR VPWR sky130_fd_sc_hd__decap_3
Xplace297 _3651_/Y VGND VGND VPWR VPWR _3893_/A2 sky130_fd_sc_hd__buf_2
Xplace286 _3906_/B1 VGND VGND VPWR VPWR _3913_/B1 sky130_fd_sc_hd__buf_2
Xplace275 _3665_/X VGND VGND VPWR VPWR _3892_/B1 sky130_fd_sc_hd__buf_2
X_6721_ _6976_/CLK _6721_/D VGND VGND VPWR VPWR _6721_/Q sky130_fd_sc_hd__dfxtp_2
X_3933_ _7373_/Q _4476_/A0 _3943_/S VGND VGND VPWR VPWR _7373_/D sky130_fd_sc_hd__mux2_2
XTAP_TAPCELL_ROW_34_657 VGND VPWR sky130_fd_sc_hd__tapvpwrvgnd_1
XFILLER_32_662 VGND VGND VPWR VPWR sky130_fd_sc_hd__fill_2
X_6652_ _6652_/A VGND VGND VPWR VPWR _6652_/Y sky130_fd_sc_hd__inv_2
X_3864_ _3864_/A0 _3863_/X _3864_/S VGND VGND VPWR VPWR _7385_/D sky130_fd_sc_hd__mux2_2
XTAP_TAPCELL_ROW_62_999 VGND VPWR sky130_fd_sc_hd__tapvpwrvgnd_1
XTAP_TAPCELL_ROW_102_1479 VGND VPWR sky130_fd_sc_hd__tapvpwrvgnd_1
XFILLER_31_194 VGND VGND VPWR VPWR sky130_fd_sc_hd__decap_3
X_6583_ _6587_/A VGND VGND VPWR VPWR _6583_/Y sky130_fd_sc_hd__inv_2
X_3795_ _6971_/Q _3889_/B1 _3881_/B1 _6721_/Q VGND VGND VPWR VPWR _3795_/X sky130_fd_sc_hd__a22o_2
XFILLER_11_17 VGND VGND VPWR VPWR sky130_fd_sc_hd__decap_3
X_7204_ _7361_/CLK _7204_/D _6484_/Y VGND VGND VPWR VPWR _7204_/Q sky130_fd_sc_hd__dfrtp_2
X_4416_ _7368_/Q _4435_/B1 _4436_/B1 _7176_/Q _4415_/X VGND VGND VPWR VPWR _4416_/X
+ sky130_fd_sc_hd__a221o_2
X_7135_ _7294_/CLK _7135_/D _6415_/Y VGND VGND VPWR VPWR _7135_/Q sky130_fd_sc_hd__dfrtp_2
X_5396_ _5396_/A0 _4978_/X _5398_/S VGND VGND VPWR VPWR _7135_/D sky130_fd_sc_hd__mux2_2
XFILLER_99_673 VGND VGND VPWR VPWR sky130_fd_sc_hd__decap_3
XFILLER_101_601 VGND VGND VPWR VPWR sky130_fd_sc_hd__decap_3
XFILLER_101_623 VGND VGND VPWR VPWR sky130_fd_sc_hd__decap_3
X_4347_ _7289_/Q _4510_/S _4346_/X _4248_/A VGND VGND VPWR VPWR _4347_/X sky130_fd_sc_hd__a211o_2
XTAP_TAPCELL_ROW_6_327 VGND VPWR sky130_fd_sc_hd__tapvpwrvgnd_1
XFILLER_100_111 VGND VGND VPWR VPWR sky130_fd_sc_hd__decap_3
XFILLER_59_548 VGND VGND VPWR VPWR sky130_fd_sc_hd__decap_3
XFILLER_86_345 VGND VGND VPWR VPWR sky130_fd_sc_hd__decap_3
X_7066_ _7258_/CLK _7066_/D _6346_/Y VGND VGND VPWR VPWR _7066_/Q sky130_fd_sc_hd__dfrtp_2
X_4278_ _7286_/Q _4522_/S _4338_/B1 _7350_/Q _3556_/A VGND VGND VPWR VPWR _4278_/X
+ sky130_fd_sc_hd__a221o_2
XFILLER_100_144 VGND VGND VPWR VPWR sky130_fd_sc_hd__decap_3
XFILLER_39_250 VGND VGND VPWR VPWR sky130_fd_sc_hd__decap_3
XFILLER_46_209 VGND VGND VPWR VPWR sky130_fd_sc_hd__decap_3
XFILLER_67_570 VGND VGND VPWR VPWR sky130_fd_sc_hd__decap_3
XFILLER_86_389 VGND VGND VPWR VPWR sky130_fd_sc_hd__decap_3
XFILLER_39_272 VGND VGND VPWR VPWR sky130_fd_sc_hd__decap_3
XFILLER_27_445 VGND VGND VPWR VPWR sky130_fd_sc_hd__decap_3
XFILLER_54_242 VGND VGND VPWR VPWR sky130_fd_sc_hd__decap_3
XFILLER_54_253 VGND VGND VPWR VPWR sky130_fd_sc_hd__decap_3
XFILLER_82_562 VGND VGND VPWR VPWR sky130_fd_sc_hd__decap_3
XTAP_TAPCELL_ROW_68_1065 VGND VPWR sky130_fd_sc_hd__tapvpwrvgnd_1
XFILLER_54_275 VGND VGND VPWR VPWR sky130_fd_sc_hd__decap_3
XFILLER_42_448 VGND VGND VPWR VPWR sky130_fd_sc_hd__decap_3
XFILLER_52_24 VGND VGND VPWR VPWR sky130_fd_sc_hd__decap_3
X_6919_ _6936_/CLK _6919_/D VGND VGND VPWR VPWR _6919_/Q sky130_fd_sc_hd__dfxtp_2
XTAP_TAPCELL_ROW_81_1221 VGND VPWR sky130_fd_sc_hd__tapvpwrvgnd_1
XFILLER_22_150 VGND VGND VPWR VPWR sky130_fd_sc_hd__decap_3
XFILLER_52_35 VGND VGND VPWR VPWR sky130_fd_sc_hd__decap_3
XFILLER_10_312 VGND VGND VPWR VPWR sky130_fd_sc_hd__decap_3
XFILLER_22_183 VGND VGND VPWR VPWR sky130_fd_sc_hd__decap_3
XFILLER_52_68 VGND VGND VPWR VPWR sky130_fd_sc_hd__decap_3
XFILLER_10_345 VGND VGND VPWR VPWR sky130_fd_sc_hd__decap_3
XFILLER_108_211 VGND VGND VPWR VPWR sky130_fd_sc_hd__decap_3
XFILLER_6_338 VGND VGND VPWR VPWR sky130_fd_sc_hd__decap_3
XTAP_TAPCELL_ROW_79_1194 VGND VPWR sky130_fd_sc_hd__tapvpwrvgnd_1
XFILLER_2_533 VGND VGND VPWR VPWR sky130_fd_sc_hd__fill_1
XFILLER_77_21 VGND VGND VPWR VPWR sky130_fd_sc_hd__decap_3
XFILLER_96_109 VGND VGND VPWR VPWR sky130_fd_sc_hd__decap_3
XTAP_TAPCELL_ROW_92_1361 VGND VPWR sky130_fd_sc_hd__tapvpwrvgnd_1
XTAP_TAPCELL_ROW_92_1350 VGND VPWR sky130_fd_sc_hd__tapvpwrvgnd_1
XFILLER_77_43 VGND VGND VPWR VPWR sky130_fd_sc_hd__decap_3
XFILLER_77_334 VGND VGND VPWR VPWR sky130_fd_sc_hd__fill_2
XFILLER_37_209 VGND VGND VPWR VPWR sky130_fd_sc_hd__decap_3
XFILLER_77_367 VGND VGND VPWR VPWR sky130_fd_sc_hd__decap_3
XFILLER_77_98 VGND VGND VPWR VPWR sky130_fd_sc_hd__decap_3
XFILLER_92_315 VGND VGND VPWR VPWR sky130_fd_sc_hd__decap_3
XFILLER_93_31 VGND VGND VPWR VPWR sky130_fd_sc_hd__decap_3
XFILLER_45_253 VGND VGND VPWR VPWR sky130_fd_sc_hd__decap_3
Xhold1090 _7338_/Q VGND VGND VPWR VPWR _4482_/A0 sky130_fd_sc_hd__dlygate4sd3_1
XFILLER_93_97 VGND VGND VPWR VPWR sky130_fd_sc_hd__decap_3
XFILLER_60_223 VGND VGND VPWR VPWR sky130_fd_sc_hd__decap_3
XFILLER_60_256 VGND VGND VPWR VPWR sky130_fd_sc_hd__decap_3
XFILLER_60_289 VGND VGND VPWR VPWR sky130_fd_sc_hd__decap_3
XFILLER_13_172 VGND VGND VPWR VPWR sky130_fd_sc_hd__decap_3
XFILLER_41_481 VGND VGND VPWR VPWR sky130_fd_sc_hd__decap_3
XFILLER_41_492 VGND VGND VPWR VPWR sky130_fd_sc_hd__decap_3
XTAP_TAPCELL_ROW_31_627 VGND VPWR sky130_fd_sc_hd__tapvpwrvgnd_1
XFILLER_9_143 VGND VGND VPWR VPWR sky130_fd_sc_hd__decap_3
X_3580_ _7033_/Q _4532_/S _4332_/B1 _7380_/Q VGND VGND VPWR VPWR _3580_/X sky130_fd_sc_hd__a22o_2
XFILLER_9_187 VGND VGND VPWR VPWR sky130_fd_sc_hd__decap_3
XTAP_TAPCELL_ROW_11_384 VGND VPWR sky130_fd_sc_hd__tapvpwrvgnd_1
XFILLER_5_382 VGND VGND VPWR VPWR sky130_fd_sc_hd__decap_3
XFILLER_114_247 VGND VGND VPWR VPWR sky130_fd_sc_hd__fill_2
XFILLER_47_3 VGND VGND VPWR VPWR sky130_fd_sc_hd__decap_3
X_4201_ _4186_/A _4636_/B _4200_/X VGND VGND VPWR VPWR _4201_/X sky130_fd_sc_hd__o21a_2
XFILLER_68_312 VGND VGND VPWR VPWR sky130_fd_sc_hd__decap_3
XFILLER_96_610 VGND VGND VPWR VPWR sky130_fd_sc_hd__decap_3
XFILLER_110_442 VGND VGND VPWR VPWR sky130_fd_sc_hd__decap_3
XFILLER_68_356 VGND VGND VPWR VPWR sky130_fd_sc_hd__decap_3
XFILLER_96_643 VGND VGND VPWR VPWR sky130_fd_sc_hd__fill_1
X_4132_ _7075_/Q _4432_/A2 _4432_/B1 _4131_/X VGND VGND VPWR VPWR _4207_/A sky130_fd_sc_hd__o211ai_2
XFILLER_110_475 VGND VGND VPWR VPWR sky130_fd_sc_hd__fill_1
XFILLER_28_209 VGND VGND VPWR VPWR sky130_fd_sc_hd__decap_3
XFILLER_56_507 VGND VGND VPWR VPWR sky130_fd_sc_hd__decap_3
XFILLER_56_529 VGND VGND VPWR VPWR sky130_fd_sc_hd__decap_3
XFILLER_68_389 VGND VGND VPWR VPWR sky130_fd_sc_hd__decap_3
XFILLER_83_315 VGND VGND VPWR VPWR sky130_fd_sc_hd__decap_3
XFILLER_95_142 VGND VGND VPWR VPWR sky130_fd_sc_hd__decap_3
X_4063_ _7116_/Q _4434_/A2 _4434_/B1 _7148_/Q VGND VGND VPWR VPWR _4063_/X sky130_fd_sc_hd__a22o_2
XTAP_TAPCELL_ROW_39_716 VGND VPWR sky130_fd_sc_hd__tapvpwrvgnd_1
XFILLER_83_337 VGND VGND VPWR VPWR sky130_fd_sc_hd__decap_3
XFILLER_36_242 VGND VGND VPWR VPWR sky130_fd_sc_hd__decap_3
XFILLER_36_253 VGND VGND VPWR VPWR sky130_fd_sc_hd__decap_3
XFILLER_64_551 VGND VGND VPWR VPWR sky130_fd_sc_hd__decap_3
XFILLER_51_212 VGND VGND VPWR VPWR sky130_fd_sc_hd__decap_3
XFILLER_64_573 VGND VGND VPWR VPWR sky130_fd_sc_hd__decap_3
XFILLER_91_370 VGND VGND VPWR VPWR sky130_fd_sc_hd__decap_3
XFILLER_51_234 VGND VGND VPWR VPWR sky130_fd_sc_hd__decap_3
X_4965_ _4965_/A0 _4964_/X _5028_/S VGND VGND VPWR VPWR _7264_/D sky130_fd_sc_hd__mux2_2
XTAP_TAPCELL_ROW_19_484 VGND VPWR sky130_fd_sc_hd__tapvpwrvgnd_1
XFILLER_51_256 VGND VGND VPWR VPWR sky130_fd_sc_hd__decap_3
XFILLER_51_278 VGND VGND VPWR VPWR sky130_fd_sc_hd__fill_2
X_6704_ _7384_/CLK _6704_/D VGND VGND VPWR VPWR _6704_/Q sky130_fd_sc_hd__dfxtp_2
X_4896_ _4896_/A _4896_/B VGND VGND VPWR VPWR _4896_/Y sky130_fd_sc_hd__nand2_2
XFILLER_22_27 VGND VGND VPWR VPWR sky130_fd_sc_hd__fill_1
XFILLER_22_38 VGND VGND VPWR VPWR sky130_fd_sc_hd__decap_3
X_6635_ _6635_/A VGND VGND VPWR VPWR _6635_/Y sky130_fd_sc_hd__inv_2
X_3847_ _6946_/Q _3656_/Y _3847_/B1 _6958_/Q _3846_/X VGND VGND VPWR VPWR _3847_/X
+ sky130_fd_sc_hd__a221o_2
X_6566_ _6567_/A VGND VGND VPWR VPWR _6566_/Y sky130_fd_sc_hd__inv_2
X_3778_ _6930_/Q _3852_/A2 _3847_/B1 _6882_/Q VGND VGND VPWR VPWR _3778_/X sky130_fd_sc_hd__a22o_2
XFILLER_3_308 VGND VGND VPWR VPWR sky130_fd_sc_hd__fill_2
XTAP_TAPCELL_ROW_115_1626 VGND VPWR sky130_fd_sc_hd__tapvpwrvgnd_1
XFILLER_105_214 VGND VGND VPWR VPWR sky130_fd_sc_hd__decap_3
XFILLER_105_225 VGND VGND VPWR VPWR sky130_fd_sc_hd__decap_3
X_6497_ _6562_/A VGND VGND VPWR VPWR _6497_/Y sky130_fd_sc_hd__inv_2
XTAP_TAPCELL_ROW_115_1637 VGND VPWR sky130_fd_sc_hd__tapvpwrvgnd_1
XFILLER_105_269 VGND VGND VPWR VPWR sky130_fd_sc_hd__decap_3
XFILLER_87_610 VGND VGND VPWR VPWR sky130_fd_sc_hd__decap_3
Xoutput495 _5651_/Y VGND VGND VPWR VPWR alu_result_out[8] sky130_fd_sc_hd__clkdlybuf4s25_1
Xoutput484 _5652_/Y VGND VGND VPWR VPWR alu_result_out[27] sky130_fd_sc_hd__clkdlybuf4s25_1
Xoutput473 _5662_/C VGND VGND VPWR VPWR alu_result_out[17] sky130_fd_sc_hd__clkdlybuf4s25_1
X_5379_ _5379_/A0 _4836_/X _5383_/S VGND VGND VPWR VPWR _7143_/D sky130_fd_sc_hd__mux2_2
XFILLER_99_470 VGND VGND VPWR VPWR sky130_fd_sc_hd__decap_3
XFILLER_59_323 VGND VGND VPWR VPWR sky130_fd_sc_hd__decap_3
XFILLER_59_334 VGND VGND VPWR VPWR sky130_fd_sc_hd__fill_2
XFILLER_87_632 VGND VGND VPWR VPWR sky130_fd_sc_hd__fill_2
XFILLER_87_643 VGND VGND VPWR VPWR sky130_fd_sc_hd__decap_3
X_7118_ _7338_/CLK _7118_/D _6398_/Y VGND VGND VPWR VPWR _7118_/Q sky130_fd_sc_hd__dfrtp_2
XFILLER_47_24 VGND VGND VPWR VPWR sky130_fd_sc_hd__decap_3
XFILLER_59_389 VGND VGND VPWR VPWR sky130_fd_sc_hd__decap_3
XFILLER_74_315 VGND VGND VPWR VPWR sky130_fd_sc_hd__decap_3
X_7049_ _7393_/CLK _7049_/D _6329_/Y VGND VGND VPWR VPWR _7049_/Q sky130_fd_sc_hd__dfrtp_2
XFILLER_101_497 VGND VGND VPWR VPWR sky130_fd_sc_hd__decap_3
XFILLER_47_57 VGND VGND VPWR VPWR sky130_fd_sc_hd__fill_2
XFILLER_47_68 VGND VGND VPWR VPWR sky130_fd_sc_hd__decap_3
XFILLER_86_197 VGND VGND VPWR VPWR sky130_fd_sc_hd__decap_3
XPHY_EDGE_ROW_29_Right_29 VGND VGND VPWR VPWR sky130_fd_sc_hd__decap_3
XFILLER_74_359 VGND VGND VPWR VPWR sky130_fd_sc_hd__decap_3
XFILLER_103_63 VGND VGND VPWR VPWR sky130_fd_sc_hd__fill_1
XFILLER_103_85 VGND VGND VPWR VPWR sky130_fd_sc_hd__decap_3
XFILLER_15_426 VGND VGND VPWR VPWR sky130_fd_sc_hd__decap_3
XFILLER_42_212 VGND VGND VPWR VPWR sky130_fd_sc_hd__decap_3
XFILLER_63_34 VGND VGND VPWR VPWR sky130_fd_sc_hd__decap_3
XFILLER_30_418 VGND VGND VPWR VPWR sky130_fd_sc_hd__fill_2
XFILLER_42_256 VGND VGND VPWR VPWR sky130_fd_sc_hd__fill_1
XFILLER_42_278 VGND VGND VPWR VPWR sky130_fd_sc_hd__decap_3
XFILLER_63_89 VGND VGND VPWR VPWR sky130_fd_sc_hd__fill_1
XFILLER_23_492 VGND VGND VPWR VPWR sky130_fd_sc_hd__decap_3
XFILLER_70_598 VGND VGND VPWR VPWR sky130_fd_sc_hd__decap_3
XFILLER_8_29 VGND VGND VPWR VPWR sky130_fd_sc_hd__decap_3
XPHY_EDGE_ROW_38_Right_38 VGND VGND VPWR VPWR sky130_fd_sc_hd__decap_3
XFILLER_109_520 VGND VGND VPWR VPWR sky130_fd_sc_hd__decap_3
XFILLER_10_175 VGND VGND VPWR VPWR sky130_fd_sc_hd__decap_3
Xwire556 _3749_/Y VGND VGND VPWR VPWR wire556/X sky130_fd_sc_hd__clkbuf_2
XFILLER_109_564 VGND VGND VPWR VPWR sky130_fd_sc_hd__decap_3
XFILLER_10_197 VGND VGND VPWR VPWR sky130_fd_sc_hd__decap_3
XFILLER_109_597 VGND VGND VPWR VPWR sky130_fd_sc_hd__fill_2
XFILLER_88_42 VGND VGND VPWR VPWR sky130_fd_sc_hd__decap_3
XFILLER_111_228 VGND VGND VPWR VPWR sky130_fd_sc_hd__decap_3
XFILLER_78_610 VGND VGND VPWR VPWR sky130_fd_sc_hd__decap_3
XFILLER_88_97 VGND VGND VPWR VPWR sky130_fd_sc_hd__decap_3
XFILLER_97_429 VGND VGND VPWR VPWR sky130_fd_sc_hd__decap_3
XFILLER_78_643 VGND VGND VPWR VPWR sky130_fd_sc_hd__fill_1
XFILLER_65_304 VGND VGND VPWR VPWR sky130_fd_sc_hd__decap_3
XFILLER_78_687 VGND VGND VPWR VPWR sky130_fd_sc_hd__decap_3
XFILLER_93_613 VGND VGND VPWR VPWR sky130_fd_sc_hd__decap_3
XPHY_EDGE_ROW_47_Right_47 VGND VGND VPWR VPWR sky130_fd_sc_hd__decap_3
XFILLER_65_337 VGND VGND VPWR VPWR sky130_fd_sc_hd__decap_3
XFILLER_77_175 VGND VGND VPWR VPWR sky130_fd_sc_hd__fill_2
XFILLER_77_186 VGND VGND VPWR VPWR sky130_fd_sc_hd__decap_3
XFILLER_92_112 VGND VGND VPWR VPWR sky130_fd_sc_hd__decap_3
XFILLER_46_551 VGND VGND VPWR VPWR sky130_fd_sc_hd__fill_1
XFILLER_80_307 VGND VGND VPWR VPWR sky130_fd_sc_hd__fill_1
XFILLER_92_167 VGND VGND VPWR VPWR sky130_fd_sc_hd__decap_3
XFILLER_18_253 VGND VGND VPWR VPWR sky130_fd_sc_hd__decap_3
XFILLER_18_286 VGND VGND VPWR VPWR sky130_fd_sc_hd__decap_3
XFILLER_33_234 VGND VGND VPWR VPWR sky130_fd_sc_hd__decap_3
XFILLER_33_278 VGND VGND VPWR VPWR sky130_fd_sc_hd__fill_2
XTAP_TAPCELL_ROW_44_774 VGND VPWR sky130_fd_sc_hd__tapvpwrvgnd_1
XTAP_TAPCELL_ROW_16_443 VGND VPWR sky130_fd_sc_hd__tapvpwrvgnd_1
X_4750_ _5647_/A _4750_/B _4750_/C VGND VGND VPWR VPWR _4751_/B sky130_fd_sc_hd__or3_2
XTAP_TAPCELL_ROW_44_785 VGND VPWR sky130_fd_sc_hd__tapvpwrvgnd_1
XPHY_EDGE_ROW_56_Right_56 VGND VGND VPWR VPWR sky130_fd_sc_hd__decap_3
X_4681_ _4982_/B _5009_/A _6992_/Q _6993_/Q _6994_/Q VGND VGND VPWR VPWR _4960_/B
+ sky130_fd_sc_hd__o2111a_2
X_3701_ _3629_/A _3700_/X _3753_/B1 VGND VGND VPWR VPWR _3701_/X sky130_fd_sc_hd__a21o_2
X_6420_ _6548_/A VGND VGND VPWR VPWR _6420_/Y sky130_fd_sc_hd__inv_2
X_3632_ _3630_/A _3501_/X _3502_/X _3505_/B _5020_/A VGND VGND VPWR VPWR _3632_/X
+ sky130_fd_sc_hd__a311o_2
X_6351_ _6388_/A VGND VGND VPWR VPWR _6351_/Y sky130_fd_sc_hd__inv_2
X_5302_ _5302_/A0 _4771_/X _5325_/S VGND VGND VPWR VPWR _7179_/D sky130_fd_sc_hd__mux2_2
XFILLER_5_190 VGND VGND VPWR VPWR sky130_fd_sc_hd__decap_3
X_6282_ _6288_/A VGND VGND VPWR VPWR _6282_/Y sky130_fd_sc_hd__inv_2
X_3494_ _7183_/Q _4471_/S _4354_/B1 _7375_/Q VGND VGND VPWR VPWR _3494_/X sky130_fd_sc_hd__a22o_2
XFILLER_102_217 VGND VGND VPWR VPWR sky130_fd_sc_hd__decap_3
XPHY_EDGE_ROW_65_Right_65 VGND VGND VPWR VPWR sky130_fd_sc_hd__decap_3
XFILLER_56_304 VGND VGND VPWR VPWR sky130_fd_sc_hd__decap_3
XFILLER_69_665 VGND VGND VPWR VPWR sky130_fd_sc_hd__decap_3
XFILLER_96_462 VGND VGND VPWR VPWR sky130_fd_sc_hd__decap_3
X_4115_ _7268_/Q _4418_/A2 _4349_/B1 _7236_/Q _4114_/X VGND VGND VPWR VPWR _4117_/B
+ sky130_fd_sc_hd__a221o_2
XTAP_TAPCELL_ROW_110_1567 VGND VPWR sky130_fd_sc_hd__tapvpwrvgnd_1
XFILLER_68_197 VGND VGND VPWR VPWR sky130_fd_sc_hd__decap_3
XFILLER_83_101 VGND VGND VPWR VPWR sky130_fd_sc_hd__decap_3
XFILLER_96_495 VGND VGND VPWR VPWR sky130_fd_sc_hd__decap_3
X_5095_ _5095_/A0 _5094_/X _5132_/S VGND VGND VPWR VPWR _7256_/D sky130_fd_sc_hd__mux2_2
XFILLER_56_348 VGND VGND VPWR VPWR sky130_fd_sc_hd__decap_3
XFILLER_83_134 VGND VGND VPWR VPWR sky130_fd_sc_hd__fill_1
XFILLER_83_156 VGND VGND VPWR VPWR sky130_fd_sc_hd__decap_3
X_4046_ _7373_/Q _4435_/B1 _4436_/B1 _7181_/Q VGND VGND VPWR VPWR _4046_/X sky130_fd_sc_hd__a22o_2
XFILLER_52_510 VGND VGND VPWR VPWR sky130_fd_sc_hd__fill_1
XFILLER_24_212 VGND VGND VPWR VPWR sky130_fd_sc_hd__decap_3
XFILLER_52_543 VGND VGND VPWR VPWR sky130_fd_sc_hd__fill_2
XTAP_TAPCELL_ROW_65_1035 VGND VPWR sky130_fd_sc_hd__tapvpwrvgnd_1
XFILLER_24_256 VGND VGND VPWR VPWR sky130_fd_sc_hd__fill_1
XFILLER_24_278 VGND VGND VPWR VPWR sky130_fd_sc_hd__decap_3
XFILLER_33_15 VGND VGND VPWR VPWR sky130_fd_sc_hd__decap_3
XPHY_EDGE_ROW_74_Right_74 VGND VGND VPWR VPWR sky130_fd_sc_hd__decap_3
XFILLER_33_48 VGND VGND VPWR VPWR sky130_fd_sc_hd__decap_3
X_4948_ _4948_/A _4948_/B VGND VGND VPWR VPWR _4948_/Y sky130_fd_sc_hd__nor2_2
X_4879_ _4879_/A0 _4878_/X _4879_/S VGND VGND VPWR VPWR _7269_/D sky130_fd_sc_hd__mux2_2
X_6618_ _6682_/A VGND VGND VPWR VPWR _6618_/Y sky130_fd_sc_hd__inv_2
XFILLER_106_523 VGND VGND VPWR VPWR sky130_fd_sc_hd__decap_3
XFILLER_3_116 VGND VGND VPWR VPWR sky130_fd_sc_hd__decap_3
X_6549_ _6584_/A VGND VGND VPWR VPWR _6549_/Y sky130_fd_sc_hd__inv_2
XFILLER_3_138 VGND VGND VPWR VPWR sky130_fd_sc_hd__fill_1
XTAP_TAPCELL_ROW_76_1164 VGND VPWR sky130_fd_sc_hd__tapvpwrvgnd_1
XPHY_EDGE_ROW_83_Right_83 VGND VGND VPWR VPWR sky130_fd_sc_hd__decap_3
XPHY_EDGE_ROW_18_Left_135 VGND VGND VPWR VPWR sky130_fd_sc_hd__decap_3
XFILLER_106_589 VGND VGND VPWR VPWR sky130_fd_sc_hd__decap_3
XFILLER_79_429 VGND VGND VPWR VPWR sky130_fd_sc_hd__decap_3
XFILLER_59_131 VGND VGND VPWR VPWR sky130_fd_sc_hd__decap_3
XFILLER_59_153 VGND VGND VPWR VPWR sky130_fd_sc_hd__decap_3
XFILLER_87_473 VGND VGND VPWR VPWR sky130_fd_sc_hd__decap_3
XFILLER_114_40 VGND VGND VPWR VPWR sky130_fd_sc_hd__decap_3
XFILLER_47_326 VGND VGND VPWR VPWR sky130_fd_sc_hd__decap_3
XFILLER_47_337 VGND VGND VPWR VPWR sky130_fd_sc_hd__decap_3
XFILLER_59_197 VGND VGND VPWR VPWR sky130_fd_sc_hd__decap_3
XFILLER_74_112 VGND VGND VPWR VPWR sky130_fd_sc_hd__decap_3
XFILLER_75_635 VGND VGND VPWR VPWR sky130_fd_sc_hd__decap_3
XFILLER_114_62 VGND VGND VPWR VPWR sky130_fd_sc_hd__decap_3
XFILLER_74_134 VGND VGND VPWR VPWR sky130_fd_sc_hd__decap_3
XFILLER_74_156 VGND VGND VPWR VPWR sky130_fd_sc_hd__decap_3
XFILLER_62_329 VGND VGND VPWR VPWR sky130_fd_sc_hd__decap_3
XFILLER_74_189 VGND VGND VPWR VPWR sky130_fd_sc_hd__decap_3
XFILLER_90_616 VGND VGND VPWR VPWR sky130_fd_sc_hd__fill_2
XPHY_EDGE_ROW_27_Left_144 VGND VGND VPWR VPWR sky130_fd_sc_hd__decap_3
XFILLER_15_223 VGND VGND VPWR VPWR sky130_fd_sc_hd__fill_1
XFILLER_15_234 VGND VGND VPWR VPWR sky130_fd_sc_hd__decap_3
XTAP_TAPCELL_ROW_87_1293 VGND VPWR sky130_fd_sc_hd__tapvpwrvgnd_1
XPHY_EDGE_ROW_92_Right_92 VGND VGND VPWR VPWR sky130_fd_sc_hd__decap_3
XFILLER_15_267 VGND VGND VPWR VPWR sky130_fd_sc_hd__decap_3
XFILLER_70_362 VGND VGND VPWR VPWR sky130_fd_sc_hd__fill_2
XFILLER_30_237 VGND VGND VPWR VPWR sky130_fd_sc_hd__decap_3
XFILLER_90_32 VGND VGND VPWR VPWR sky130_fd_sc_hd__decap_3
XTAP_TAPCELL_ROW_13_413 VGND VPWR sky130_fd_sc_hd__tapvpwrvgnd_1
XTAP_TAPCELL_ROW_13_402 VGND VPWR sky130_fd_sc_hd__tapvpwrvgnd_1
XFILLER_30_259 VGND VGND VPWR VPWR sky130_fd_sc_hd__decap_3
XFILLER_90_65 VGND VGND VPWR VPWR sky130_fd_sc_hd__decap_3
XTAP_TAPCELL_ROW_41_744 VGND VPWR sky130_fd_sc_hd__tapvpwrvgnd_1
XFILLER_23_81 VGND VGND VPWR VPWR sky130_fd_sc_hd__decap_3
XFILLER_7_433 VGND VGND VPWR VPWR sky130_fd_sc_hd__fill_1
XFILLER_116_309 VGND VGND VPWR VPWR sky130_fd_sc_hd__fill_1
XFILLER_7_455 VGND VGND VPWR VPWR sky130_fd_sc_hd__decap_3
XPHY_EDGE_ROW_36_Left_153 VGND VGND VPWR VPWR sky130_fd_sc_hd__decap_3
XFILLER_109_361 VGND VGND VPWR VPWR sky130_fd_sc_hd__decap_3
XFILLER_99_63 VGND VGND VPWR VPWR sky130_fd_sc_hd__decap_3
XFILLER_99_52 VGND VGND VPWR VPWR sky130_fd_sc_hd__decap_3
XFILLER_99_96 VGND VGND VPWR VPWR sky130_fd_sc_hd__decap_3
XFILLER_31_6 VGND VGND VPWR VPWR sky130_fd_sc_hd__decap_3
XFILLER_78_440 VGND VGND VPWR VPWR sky130_fd_sc_hd__decap_3
XFILLER_65_101 VGND VGND VPWR VPWR sky130_fd_sc_hd__decap_3
XFILLER_66_635 VGND VGND VPWR VPWR sky130_fd_sc_hd__decap_3
XFILLER_78_473 VGND VGND VPWR VPWR sky130_fd_sc_hd__decap_3
XFILLER_66_668 VGND VGND VPWR VPWR sky130_fd_sc_hd__decap_3
XFILLER_93_465 VGND VGND VPWR VPWR sky130_fd_sc_hd__decap_3
Xsingle_cycle_cpu_585 VGND VGND VPWR VPWR instruction_out[0] single_cycle_cpu_585/LO
+ sky130_fd_sc_hd__conb_1
XTAP_TAPCELL_ROW_49_844 VGND VPWR sky130_fd_sc_hd__tapvpwrvgnd_1
XPHY_EDGE_ROW_45_Left_162 VGND VGND VPWR VPWR sky130_fd_sc_hd__decap_3
XFILLER_0_41 VGND VGND VPWR VPWR sky130_fd_sc_hd__fill_1
XFILLER_53_329 VGND VGND VPWR VPWR sky130_fd_sc_hd__decap_3
XFILLER_65_178 VGND VGND VPWR VPWR sky130_fd_sc_hd__decap_3
XFILLER_81_638 VGND VGND VPWR VPWR sky130_fd_sc_hd__fill_2
XFILLER_0_85 VGND VGND VPWR VPWR sky130_fd_sc_hd__fill_1
XFILLER_46_392 VGND VGND VPWR VPWR sky130_fd_sc_hd__decap_3
XFILLER_74_690 VGND VGND VPWR VPWR sky130_fd_sc_hd__fill_2
XFILLER_80_137 VGND VGND VPWR VPWR sky130_fd_sc_hd__decap_3
XFILLER_81_649 VGND VGND VPWR VPWR sky130_fd_sc_hd__fill_1
XFILLER_21_237 VGND VGND VPWR VPWR sky130_fd_sc_hd__decap_3
XFILLER_61_373 VGND VGND VPWR VPWR sky130_fd_sc_hd__fill_2
XFILLER_61_384 VGND VGND VPWR VPWR sky130_fd_sc_hd__fill_1
X_4802_ _7002_/Q _5605_/B _4834_/A VGND VGND VPWR VPWR _4802_/X sky130_fd_sc_hd__o21a_2
XPHY_EDGE_ROW_100_Right_100 VGND VGND VPWR VPWR sky130_fd_sc_hd__decap_3
XFILLER_9_72 VGND VGND VPWR VPWR sky130_fd_sc_hd__decap_3
XFILLER_9_50 VGND VGND VPWR VPWR sky130_fd_sc_hd__decap_3
XPHY_EDGE_ROW_54_Left_171 VGND VGND VPWR VPWR sky130_fd_sc_hd__decap_3
X_6403_ _6599_/A VGND VGND VPWR VPWR _6403_/Y sky130_fd_sc_hd__inv_2
X_4664_ _4664_/A _4664_/B _5665_/A VGND VGND VPWR VPWR _4664_/X sky130_fd_sc_hd__or3b_4
X_7383_ _7383_/CLK _7383_/D _6663_/Y VGND VGND VPWR VPWR _7383_/Q sky130_fd_sc_hd__dfrtp_2
Xhold901 _7091_/Q VGND VGND VPWR VPWR _7091_/D sky130_fd_sc_hd__dlygate4sd3_1
Xhold912 _6718_/Q VGND VGND VPWR VPWR hold912/X sky130_fd_sc_hd__dlygate4sd3_1
X_4595_ _4595_/A _4595_/B VGND VGND VPWR VPWR _7283_/D sky130_fd_sc_hd__and2_2
X_3615_ _3508_/A _3547_/Y _3427_/B VGND VGND VPWR VPWR _3616_/B sky130_fd_sc_hd__o21ai_2
XFILLER_115_320 VGND VGND VPWR VPWR sky130_fd_sc_hd__decap_3
Xhold923 _6696_/Q VGND VGND VPWR VPWR hold923/X sky130_fd_sc_hd__dlygate4sd3_1
Xhold934 _6703_/Q VGND VGND VPWR VPWR hold934/X sky130_fd_sc_hd__dlygate4sd3_1
Xhold945 _6710_/Q VGND VGND VPWR VPWR hold945/X sky130_fd_sc_hd__dlygate4sd3_1
X_6334_ _6684_/A VGND VGND VPWR VPWR _6334_/Y sky130_fd_sc_hd__inv_2
X_3546_ _3630_/A _3630_/B _3635_/A _3636_/A VGND VGND VPWR VPWR _3547_/B sky130_fd_sc_hd__a211o_2
XFILLER_115_353 VGND VGND VPWR VPWR sky130_fd_sc_hd__decap_3
Xhold989 _7258_/Q VGND VGND VPWR VPWR hold989/X sky130_fd_sc_hd__dlygate4sd3_1
Xhold978 _7375_/Q VGND VGND VPWR VPWR hold978/X sky130_fd_sc_hd__dlygate4sd3_1
Xhold967 _6692_/Q VGND VGND VPWR VPWR hold967/X sky130_fd_sc_hd__dlygate4sd3_1
Xhold956 _7379_/Q VGND VGND VPWR VPWR hold956/X sky130_fd_sc_hd__dlygate4sd3_1
X_6265_ _6522_/A VGND VGND VPWR VPWR _6265_/Y sky130_fd_sc_hd__inv_2
XFILLER_88_226 VGND VGND VPWR VPWR sky130_fd_sc_hd__decap_3
X_3477_ _7184_/Q _3996_/S _3380_/Y _7376_/Q VGND VGND VPWR VPWR _3477_/X sky130_fd_sc_hd__a22o_2
XFILLER_88_259 VGND VGND VPWR VPWR sky130_fd_sc_hd__decap_3
XFILLER_28_15 VGND VGND VPWR VPWR sky130_fd_sc_hd__decap_3
XFILLER_29_304 VGND VGND VPWR VPWR sky130_fd_sc_hd__decap_3
XFILLER_29_337 VGND VGND VPWR VPWR sky130_fd_sc_hd__fill_1
XFILLER_84_421 VGND VGND VPWR VPWR sky130_fd_sc_hd__decap_3
X_5147_ _5145_/A _3541_/X _5146_/Y VGND VGND VPWR VPWR _5147_/X sky130_fd_sc_hd__a21o_2
XPHY_EDGE_ROW_63_Left_180 VGND VGND VPWR VPWR sky130_fd_sc_hd__decap_3
XFILLER_56_134 VGND VGND VPWR VPWR sky130_fd_sc_hd__decap_3
XFILLER_56_156 VGND VGND VPWR VPWR sky130_fd_sc_hd__decap_3
XFILLER_84_465 VGND VGND VPWR VPWR sky130_fd_sc_hd__decap_3
XFILLER_96_292 VGND VGND VPWR VPWR sky130_fd_sc_hd__decap_3
X_5078_ _5577_/S _5069_/X _5077_/X _4467_/B _5666_/A VGND VGND VPWR VPWR _5078_/X
+ sky130_fd_sc_hd__a221o_2
XFILLER_44_318 VGND VGND VPWR VPWR sky130_fd_sc_hd__decap_3
XFILLER_56_189 VGND VGND VPWR VPWR sky130_fd_sc_hd__decap_3
XFILLER_72_638 VGND VGND VPWR VPWR sky130_fd_sc_hd__decap_3
XFILLER_84_498 VGND VGND VPWR VPWR sky130_fd_sc_hd__decap_3
XFILLER_37_370 VGND VGND VPWR VPWR sky130_fd_sc_hd__decap_3
XFILLER_44_25 VGND VGND VPWR VPWR sky130_fd_sc_hd__decap_3
XFILLER_71_126 VGND VGND VPWR VPWR sky130_fd_sc_hd__decap_3
XFILLER_44_58 VGND VGND VPWR VPWR sky130_fd_sc_hd__decap_3
XFILLER_52_351 VGND VGND VPWR VPWR sky130_fd_sc_hd__decap_3
XFILLER_100_20 VGND VGND VPWR VPWR sky130_fd_sc_hd__decap_3
XFILLER_12_215 VGND VGND VPWR VPWR sky130_fd_sc_hd__decap_3
XFILLER_100_53 VGND VGND VPWR VPWR sky130_fd_sc_hd__decap_3
XFILLER_100_64 VGND VGND VPWR VPWR sky130_fd_sc_hd__decap_3
XFILLER_12_237 VGND VGND VPWR VPWR sky130_fd_sc_hd__decap_3
XFILLER_12_259 VGND VGND VPWR VPWR sky130_fd_sc_hd__decap_3
XFILLER_60_24 VGND VGND VPWR VPWR sky130_fd_sc_hd__decap_3
XFILLER_20_292 VGND VGND VPWR VPWR sky130_fd_sc_hd__decap_3
XFILLER_60_79 VGND VGND VPWR VPWR sky130_fd_sc_hd__decap_3
XFILLER_109_40 VGND VGND VPWR VPWR sky130_fd_sc_hd__decap_3
XFILLER_114_3 VGND VGND VPWR VPWR sky130_fd_sc_hd__decap_3
XFILLER_4_414 VGND VGND VPWR VPWR sky130_fd_sc_hd__decap_3
XFILLER_106_342 VGND VGND VPWR VPWR sky130_fd_sc_hd__decap_3
XFILLER_69_33 VGND VGND VPWR VPWR sky130_fd_sc_hd__fill_2
XFILLER_69_55 VGND VGND VPWR VPWR sky130_fd_sc_hd__fill_1
XFILLER_69_66 VGND VGND VPWR VPWR sky130_fd_sc_hd__decap_3
XFILLER_79_204 VGND VGND VPWR VPWR sky130_fd_sc_hd__decap_3
XFILLER_106_386 VGND VGND VPWR VPWR sky130_fd_sc_hd__fill_1
XFILLER_69_99 VGND VGND VPWR VPWR sky130_fd_sc_hd__decap_3
XFILLER_79_248 VGND VGND VPWR VPWR sky130_fd_sc_hd__decap_3
XFILLER_0_653 VGND VGND VPWR VPWR sky130_fd_sc_hd__fill_2
XFILLER_85_32 VGND VGND VPWR VPWR sky130_fd_sc_hd__decap_3
XFILLER_87_281 VGND VGND VPWR VPWR sky130_fd_sc_hd__decap_3
XFILLER_94_218 VGND VGND VPWR VPWR sky130_fd_sc_hd__decap_3
XTAP_TAPCELL_ROW_89_1322 VGND VPWR sky130_fd_sc_hd__tapvpwrvgnd_1
XFILLER_102_592 VGND VGND VPWR VPWR sky130_fd_sc_hd__decap_3
XFILLER_85_54 VGND VGND VPWR VPWR sky130_fd_sc_hd__fill_2
XFILLER_47_167 VGND VGND VPWR VPWR sky130_fd_sc_hd__fill_1
XFILLER_47_178 VGND VGND VPWR VPWR sky130_fd_sc_hd__decap_3
XFILLER_75_476 VGND VGND VPWR VPWR sky130_fd_sc_hd__decap_3
XFILLER_85_87 VGND VGND VPWR VPWR sky130_fd_sc_hd__decap_3
XFILLER_90_402 VGND VGND VPWR VPWR sky130_fd_sc_hd__decap_3
XTAP_TAPCELL_ROW_46_803 VGND VPWR sky130_fd_sc_hd__tapvpwrvgnd_1
XFILLER_18_81 VGND VGND VPWR VPWR sky130_fd_sc_hd__decap_3
XFILLER_28_381 VGND VGND VPWR VPWR sky130_fd_sc_hd__decap_3
XFILLER_62_137 VGND VGND VPWR VPWR sky130_fd_sc_hd__decap_3
XFILLER_62_148 VGND VGND VPWR VPWR sky130_fd_sc_hd__decap_3
XFILLER_90_446 VGND VGND VPWR VPWR sky130_fd_sc_hd__fill_1
XFILLER_43_340 VGND VGND VPWR VPWR sky130_fd_sc_hd__decap_3
XFILLER_70_181 VGND VGND VPWR VPWR sky130_fd_sc_hd__fill_1
XFILLER_71_682 VGND VGND VPWR VPWR sky130_fd_sc_hd__decap_3
XTAP_TAPCELL_ROW_26_560 VGND VPWR sky130_fd_sc_hd__tapvpwrvgnd_1
XFILLER_11_270 VGND VGND VPWR VPWR sky130_fd_sc_hd__decap_3
XFILLER_11_281 VGND VGND VPWR VPWR sky130_fd_sc_hd__decap_3
XFILLER_7_241 VGND VGND VPWR VPWR sky130_fd_sc_hd__decap_3
XFILLER_7_274 VGND VGND VPWR VPWR sky130_fd_sc_hd__decap_3
XFILLER_109_191 VGND VGND VPWR VPWR sky130_fd_sc_hd__decap_3
XFILLER_116_139 VGND VGND VPWR VPWR sky130_fd_sc_hd__fill_1
XFILLER_7_296 VGND VGND VPWR VPWR sky130_fd_sc_hd__decap_3
X_4380_ _4380_/A _4380_/B VGND VGND VPWR VPWR _4381_/B sky130_fd_sc_hd__or2_2
X_3400_ _3449_/B VGND VGND VPWR VPWR _3421_/B sky130_fd_sc_hd__inv_2
X_3331_ _3365_/A _3362_/A _3371_/A VGND VGND VPWR VPWR _3528_/A sky130_fd_sc_hd__or3b_2
XFILLER_98_513 VGND VGND VPWR VPWR sky130_fd_sc_hd__decap_3
XFILLER_112_323 VGND VGND VPWR VPWR sky130_fd_sc_hd__decap_3
XFILLER_98_557 VGND VGND VPWR VPWR sky130_fd_sc_hd__decap_3
XFILLER_112_356 VGND VGND VPWR VPWR sky130_fd_sc_hd__decap_3
XFILLER_100_518 VGND VGND VPWR VPWR sky130_fd_sc_hd__decap_3
XFILLER_112_389 VGND VGND VPWR VPWR sky130_fd_sc_hd__decap_3
XFILLER_38_112 VGND VGND VPWR VPWR sky130_fd_sc_hd__decap_3
XFILLER_66_410 VGND VGND VPWR VPWR sky130_fd_sc_hd__decap_3
XFILLER_66_421 VGND VGND VPWR VPWR sky130_fd_sc_hd__decap_3
XFILLER_85_218 VGND VGND VPWR VPWR sky130_fd_sc_hd__decap_3
X_5001_ _5001_/A _5001_/B VGND VGND VPWR VPWR _6991_/D sky130_fd_sc_hd__nor2_2
XFILLER_66_454 VGND VGND VPWR VPWR sky130_fd_sc_hd__fill_2
XFILLER_26_318 VGND VGND VPWR VPWR sky130_fd_sc_hd__decap_3
XFILLER_38_156 VGND VGND VPWR VPWR sky130_fd_sc_hd__decap_3
XFILLER_81_402 VGND VGND VPWR VPWR sky130_fd_sc_hd__decap_3
XFILLER_93_262 VGND VGND VPWR VPWR sky130_fd_sc_hd__decap_3
XFILLER_19_381 VGND VGND VPWR VPWR sky130_fd_sc_hd__decap_3
XFILLER_38_189 VGND VGND VPWR VPWR sky130_fd_sc_hd__decap_3
XFILLER_66_498 VGND VGND VPWR VPWR sky130_fd_sc_hd__decap_3
XFILLER_81_446 VGND VGND VPWR VPWR sky130_fd_sc_hd__fill_2
X_6952_ _6972_/CLK _6952_/D VGND VGND VPWR VPWR _6952_/Q sky130_fd_sc_hd__dfxtp_2
XFILLER_34_351 VGND VGND VPWR VPWR sky130_fd_sc_hd__decap_3
XFILLER_81_479 VGND VGND VPWR VPWR sky130_fd_sc_hd__decap_3
X_6883_ _7390_/CLK _6883_/D VGND VGND VPWR VPWR _6883_/Q sky130_fd_sc_hd__dfxtp_2
XFILLER_14_17 VGND VGND VPWR VPWR sky130_fd_sc_hd__fill_2
XFILLER_34_384 VGND VGND VPWR VPWR sky130_fd_sc_hd__decap_3
XFILLER_34_395 VGND VGND VPWR VPWR sky130_fd_sc_hd__decap_3
XFILLER_61_181 VGND VGND VPWR VPWR sky130_fd_sc_hd__decap_3
XFILLER_108_607 VGND VGND VPWR VPWR sky130_fd_sc_hd__fill_2
XFILLER_108_618 VGND VGND VPWR VPWR sky130_fd_sc_hd__decap_3
X_4716_ _5092_/C _4664_/X _4695_/X _7008_/D _4997_/A1 VGND VGND VPWR VPWR _4716_/X
+ sky130_fd_sc_hd__a32o_2
X_4647_ _4813_/A _4827_/A _4795_/A _4787_/A VGND VGND VPWR VPWR _4647_/X sky130_fd_sc_hd__and4_2
X_7366_ _7393_/CLK _7366_/D _6646_/Y VGND VGND VPWR VPWR _7366_/Q sky130_fd_sc_hd__dfrtp_2
Xhold720 _6737_/Q VGND VGND VPWR VPWR _6737_/D sky130_fd_sc_hd__dlygate4sd3_1
XFILLER_100_9 VGND VGND VPWR VPWR sky130_fd_sc_hd__decap_3
XFILLER_116_673 VGND VGND VPWR VPWR sky130_fd_sc_hd__decap_3
XFILLER_1_406 VGND VGND VPWR VPWR sky130_fd_sc_hd__fill_1
Xhold731 _6791_/Q VGND VGND VPWR VPWR _6791_/D sky130_fd_sc_hd__dlygate4sd3_1
Xhold742 _6917_/Q VGND VGND VPWR VPWR _6917_/D sky130_fd_sc_hd__dlygate4sd3_1
Xhold753 _6747_/Q VGND VGND VPWR VPWR _6747_/D sky130_fd_sc_hd__dlygate4sd3_1
Xhold764 _6727_/Q VGND VGND VPWR VPWR _6727_/D sky130_fd_sc_hd__dlygate4sd3_1
X_6317_ _6562_/A VGND VGND VPWR VPWR _6317_/Y sky130_fd_sc_hd__inv_2
XTAP_TAPCELL_ROW_73_1123 VGND VPWR sky130_fd_sc_hd__tapvpwrvgnd_1
XFILLER_103_323 VGND VGND VPWR VPWR sky130_fd_sc_hd__decap_3
XFILLER_1_428 VGND VGND VPWR VPWR sky130_fd_sc_hd__decap_3
XFILLER_89_546 VGND VGND VPWR VPWR sky130_fd_sc_hd__decap_3
X_7297_ _7363_/CLK _7297_/D _6577_/Y VGND VGND VPWR VPWR _7297_/Q sky130_fd_sc_hd__dfrtp_2
Xhold775 _6866_/Q VGND VGND VPWR VPWR _6866_/D sky130_fd_sc_hd__dlygate4sd3_1
Xhold786 _6790_/Q VGND VGND VPWR VPWR _6790_/D sky130_fd_sc_hd__dlygate4sd3_1
Xhold797 _6720_/Q VGND VGND VPWR VPWR _6720_/D sky130_fd_sc_hd__dlygate4sd3_1
XFILLER_103_367 VGND VGND VPWR VPWR sky130_fd_sc_hd__decap_3
XFILLER_39_36 VGND VGND VPWR VPWR sky130_fd_sc_hd__decap_3
XFILLER_69_270 VGND VGND VPWR VPWR sky130_fd_sc_hd__decap_3
XFILLER_76_229 VGND VGND VPWR VPWR sky130_fd_sc_hd__decap_3
XFILLER_69_281 VGND VGND VPWR VPWR sky130_fd_sc_hd__decap_3
XFILLER_84_240 VGND VGND VPWR VPWR sky130_fd_sc_hd__decap_3
XFILLER_29_167 VGND VGND VPWR VPWR sky130_fd_sc_hd__fill_1
XFILLER_29_178 VGND VGND VPWR VPWR sky130_fd_sc_hd__decap_3
XFILLER_72_413 VGND VGND VPWR VPWR sky130_fd_sc_hd__decap_3
XTAP_TAPCELL_ROW_4_299 VGND VPWR sky130_fd_sc_hd__tapvpwrvgnd_1
XFILLER_17_329 VGND VGND VPWR VPWR sky130_fd_sc_hd__decap_3
XFILLER_44_137 VGND VGND VPWR VPWR sky130_fd_sc_hd__decap_3
XFILLER_55_57 VGND VGND VPWR VPWR sky130_fd_sc_hd__decap_3
XFILLER_57_498 VGND VGND VPWR VPWR sky130_fd_sc_hd__decap_3
XFILLER_72_424 VGND VGND VPWR VPWR sky130_fd_sc_hd__decap_3
XFILLER_25_340 VGND VGND VPWR VPWR sky130_fd_sc_hd__decap_3
XFILLER_72_457 VGND VGND VPWR VPWR sky130_fd_sc_hd__decap_3
XFILLER_111_52 VGND VGND VPWR VPWR sky130_fd_sc_hd__decap_3
XFILLER_111_63 VGND VGND VPWR VPWR sky130_fd_sc_hd__fill_2
XFILLER_25_373 VGND VGND VPWR VPWR sky130_fd_sc_hd__decap_3
XTAP_TAPCELL_ROW_84_1263 VGND VPWR sky130_fd_sc_hd__tapvpwrvgnd_1
XFILLER_40_321 VGND VGND VPWR VPWR sky130_fd_sc_hd__decap_3
XFILLER_52_192 VGND VGND VPWR VPWR sky130_fd_sc_hd__decap_3
XTAP_TAPCELL_ROW_23_530 VGND VPWR sky130_fd_sc_hd__tapvpwrvgnd_1
XFILLER_40_354 VGND VGND VPWR VPWR sky130_fd_sc_hd__decap_3
XFILLER_40_365 VGND VGND VPWR VPWR sky130_fd_sc_hd__decap_3
XFILLER_71_78 VGND VGND VPWR VPWR sky130_fd_sc_hd__decap_3
XTAP_TAPCELL_ROW_51_861 VGND VPWR sky130_fd_sc_hd__tapvpwrvgnd_1
XFILLER_4_200 VGND VGND VPWR VPWR sky130_fd_sc_hd__decap_3
XFILLER_4_233 VGND VGND VPWR VPWR sky130_fd_sc_hd__decap_3
XFILLER_106_161 VGND VGND VPWR VPWR sky130_fd_sc_hd__decap_3
XFILLER_20_71 VGND VGND VPWR VPWR sky130_fd_sc_hd__fill_1
XFILLER_20_82 VGND VGND VPWR VPWR sky130_fd_sc_hd__fill_2
XFILLER_4_288 VGND VGND VPWR VPWR sky130_fd_sc_hd__decap_3
XFILLER_96_20 VGND VGND VPWR VPWR sky130_fd_sc_hd__decap_3
XTAP_TAPCELL_ROW_95_1392 VGND VPWR sky130_fd_sc_hd__tapvpwrvgnd_1
XFILLER_95_505 VGND VGND VPWR VPWR sky130_fd_sc_hd__decap_3
XFILLER_67_207 VGND VGND VPWR VPWR sky130_fd_sc_hd__decap_3
XFILLER_95_538 VGND VGND VPWR VPWR sky130_fd_sc_hd__decap_3
XFILLER_48_421 VGND VGND VPWR VPWR sky130_fd_sc_hd__decap_3
XFILLER_48_454 VGND VGND VPWR VPWR sky130_fd_sc_hd__decap_3
XFILLER_96_97 VGND VGND VPWR VPWR sky130_fd_sc_hd__decap_3
XFILLER_63_402 VGND VGND VPWR VPWR sky130_fd_sc_hd__decap_3
XFILLER_75_240 VGND VGND VPWR VPWR sky130_fd_sc_hd__decap_3
XTAP_TAPCELL_ROW_59_961 VGND VPWR sky130_fd_sc_hd__tapvpwrvgnd_1
XFILLER_35_137 VGND VGND VPWR VPWR sky130_fd_sc_hd__decap_3
XFILLER_63_435 VGND VGND VPWR VPWR sky130_fd_sc_hd__decap_3
XFILLER_75_284 VGND VGND VPWR VPWR sky130_fd_sc_hd__fill_1
XFILLER_90_210 VGND VGND VPWR VPWR sky130_fd_sc_hd__decap_3
Xplace402 _4534_/S VGND VGND VPWR VPWR _3562_/A sky130_fd_sc_hd__buf_2
Xplace413 _4419_/B1 VGND VGND VPWR VPWR _4196_/A2 sky130_fd_sc_hd__buf_2
XFILLER_16_351 VGND VGND VPWR VPWR sky130_fd_sc_hd__fill_2
XFILLER_90_243 VGND VGND VPWR VPWR sky130_fd_sc_hd__decap_3
Xplace424 _4414_/B1 VGND VGND VPWR VPWR _3958_/S sky130_fd_sc_hd__buf_2
Xplace435 _3368_/Y VGND VGND VPWR VPWR _3394_/A sky130_fd_sc_hd__buf_2
Xplace446 _5634_/B VGND VGND VPWR VPWR _5611_/B sky130_fd_sc_hd__buf_2
XFILLER_50_118 VGND VGND VPWR VPWR sky130_fd_sc_hd__decap_3
XFILLER_90_298 VGND VGND VPWR VPWR sky130_fd_sc_hd__decap_3
Xplace457 _3386_/A VGND VGND VPWR VPWR _3561_/A sky130_fd_sc_hd__buf_2
XFILLER_31_343 VGND VGND VPWR VPWR sky130_fd_sc_hd__decap_3
XFILLER_43_181 VGND VGND VPWR VPWR sky130_fd_sc_hd__decap_3
XFILLER_71_490 VGND VGND VPWR VPWR sky130_fd_sc_hd__decap_3
X_3880_ _3714_/X _3877_/X _3879_/X _3735_/X VGND VGND VPWR VPWR _3880_/X sky130_fd_sc_hd__a22o_2
XFILLER_77_3 VGND VGND VPWR VPWR sky130_fd_sc_hd__decap_3
X_4501_ _4501_/A0 _7297_/Q _4501_/S VGND VGND VPWR VPWR _7329_/D sky130_fd_sc_hd__mux2_2
X_7220_ clkload4/A _7220_/D _6500_/Y VGND VGND VPWR VPWR _7220_/Q sky130_fd_sc_hd__dfrtp_2
X_4432_ _7079_/Q _4432_/A2 _4432_/B1 _4431_/X VGND VGND VPWR VPWR _4440_/A sky130_fd_sc_hd__o211ai_2
XFILLER_6_73 VGND VGND VPWR VPWR sky130_fd_sc_hd__decap_3
XFILLER_116_19 VGND VGND VPWR VPWR sky130_fd_sc_hd__fill_1
X_7151_ _7360_/CLK _7151_/D _6431_/Y VGND VGND VPWR VPWR _7151_/Q sky130_fd_sc_hd__dfrtp_2
X_4363_ _4619_/B VGND VGND VPWR VPWR _4369_/A sky130_fd_sc_hd__inv_2
XFILLER_98_332 VGND VGND VPWR VPWR sky130_fd_sc_hd__decap_3
XFILLER_98_321 VGND VGND VPWR VPWR sky130_fd_sc_hd__fill_1
X_7082_ _7330_/CLK _7082_/D _6362_/Y VGND VGND VPWR VPWR _7082_/Q sky130_fd_sc_hd__dfrtp_2
X_4294_ _4612_/A _4612_/B VGND VGND VPWR VPWR _5113_/A sky130_fd_sc_hd__xor2_2
X_3314_ _4467_/A _4467_/B VGND VGND VPWR VPWR _5647_/A sky130_fd_sc_hd__or2_2
XFILLER_98_365 VGND VGND VPWR VPWR sky130_fd_sc_hd__decap_3
XFILLER_112_164 VGND VGND VPWR VPWR sky130_fd_sc_hd__decap_3
XFILLER_58_218 VGND VGND VPWR VPWR sky130_fd_sc_hd__decap_3
XFILLER_98_398 VGND VGND VPWR VPWR sky130_fd_sc_hd__decap_3
XFILLER_100_348 VGND VGND VPWR VPWR sky130_fd_sc_hd__fill_2
XFILLER_112_197 VGND VGND VPWR VPWR sky130_fd_sc_hd__decap_3
XFILLER_66_251 VGND VGND VPWR VPWR sky130_fd_sc_hd__fill_1
XFILLER_66_262 VGND VGND VPWR VPWR sky130_fd_sc_hd__decap_3
XFILLER_26_115 VGND VGND VPWR VPWR sky130_fd_sc_hd__decap_3
XFILLER_54_424 VGND VGND VPWR VPWR sky130_fd_sc_hd__decap_3
XFILLER_66_295 VGND VGND VPWR VPWR sky130_fd_sc_hd__decap_3
XTAP_TAPCELL_ROW_1_258 VGND VPWR sky130_fd_sc_hd__tapvpwrvgnd_1
XTAP_TAPCELL_ROW_107_1539 VGND VPWR sky130_fd_sc_hd__tapvpwrvgnd_1
XFILLER_26_159 VGND VGND VPWR VPWR sky130_fd_sc_hd__decap_3
XFILLER_54_468 VGND VGND VPWR VPWR sky130_fd_sc_hd__decap_3
XFILLER_81_243 VGND VGND VPWR VPWR sky130_fd_sc_hd__decap_3
X_6935_ _7198_/CLK _6935_/D VGND VGND VPWR VPWR _6935_/Q sky130_fd_sc_hd__dfxtp_2
XTAP_TAPCELL_ROW_1_269 VGND VPWR sky130_fd_sc_hd__tapvpwrvgnd_1
XFILLER_34_170 VGND VGND VPWR VPWR sky130_fd_sc_hd__decap_3
XFILLER_41_107 VGND VGND VPWR VPWR sky130_fd_sc_hd__decap_3
XFILLER_81_287 VGND VGND VPWR VPWR sky130_fd_sc_hd__decap_3
XTAP_TAPCELL_ROW_37_699 VGND VPWR sky130_fd_sc_hd__tapvpwrvgnd_1
X_6866_ _6936_/CLK _6866_/D VGND VGND VPWR VPWR _6866_/Q sky130_fd_sc_hd__dfxtp_2
XFILLER_10_505 VGND VGND VPWR VPWR sky130_fd_sc_hd__fill_1
XFILLER_22_354 VGND VGND VPWR VPWR sky130_fd_sc_hd__decap_3
XFILLER_22_365 VGND VGND VPWR VPWR sky130_fd_sc_hd__decap_3
X_6797_ _7198_/CLK _6797_/D VGND VGND VPWR VPWR _6797_/Q sky130_fd_sc_hd__dfxtp_2
XFILLER_22_398 VGND VGND VPWR VPWR sky130_fd_sc_hd__decap_3
XFILLER_108_459 VGND VGND VPWR VPWR sky130_fd_sc_hd__decap_3
XFILLER_1_214 VGND VGND VPWR VPWR sky130_fd_sc_hd__decap_3
X_7349_ clkload3/A _7349_/D _6629_/Y VGND VGND VPWR VPWR _7349_/Q sky130_fd_sc_hd__dfrtp_2
XTAP_TAPCELL_ROW_9_358 VGND VPWR sky130_fd_sc_hd__tapvpwrvgnd_1
XFILLER_9_6 VGND VGND VPWR VPWR sky130_fd_sc_hd__decap_3
XFILLER_77_505 VGND VGND VPWR VPWR sky130_fd_sc_hd__decap_3
Xhold594 _6864_/Q VGND VGND VPWR VPWR _6864_/D sky130_fd_sc_hd__dlygate4sd3_1
XFILLER_103_153 VGND VGND VPWR VPWR sky130_fd_sc_hd__decap_3
XFILLER_106_52 VGND VGND VPWR VPWR sky130_fd_sc_hd__decap_3
XFILLER_77_538 VGND VGND VPWR VPWR sky130_fd_sc_hd__fill_2
XFILLER_89_387 VGND VGND VPWR VPWR sky130_fd_sc_hd__decap_3
XFILLER_106_74 VGND VGND VPWR VPWR sky130_fd_sc_hd__decap_3
XFILLER_106_96 VGND VGND VPWR VPWR sky130_fd_sc_hd__decap_3
XFILLER_66_23 VGND VGND VPWR VPWR sky130_fd_sc_hd__decap_3
XFILLER_18_616 VGND VGND VPWR VPWR sky130_fd_sc_hd__decap_3
XFILLER_45_402 VGND VGND VPWR VPWR sky130_fd_sc_hd__decap_3
XFILLER_57_240 VGND VGND VPWR VPWR sky130_fd_sc_hd__decap_3
XFILLER_85_571 VGND VGND VPWR VPWR sky130_fd_sc_hd__fill_2
XFILLER_57_284 VGND VGND VPWR VPWR sky130_fd_sc_hd__decap_3
XFILLER_66_89 VGND VGND VPWR VPWR sky130_fd_sc_hd__decap_3
XTAP_TAPCELL_ROW_56_920 VGND VPWR sky130_fd_sc_hd__tapvpwrvgnd_1
XFILLER_45_479 VGND VGND VPWR VPWR sky130_fd_sc_hd__decap_3
XFILLER_72_243 VGND VGND VPWR VPWR sky130_fd_sc_hd__decap_3
XFILLER_32_118 VGND VGND VPWR VPWR sky130_fd_sc_hd__decap_3
XFILLER_60_427 VGND VGND VPWR VPWR sky130_fd_sc_hd__decap_3
XFILLER_72_298 VGND VGND VPWR VPWR sky130_fd_sc_hd__decap_3
XFILLER_82_44 VGND VGND VPWR VPWR sky130_fd_sc_hd__decap_3
XFILLER_13_332 VGND VGND VPWR VPWR sky130_fd_sc_hd__decap_3
XFILLER_25_181 VGND VGND VPWR VPWR sky130_fd_sc_hd__decap_3
XFILLER_53_490 VGND VGND VPWR VPWR sky130_fd_sc_hd__decap_3
XFILLER_40_162 VGND VGND VPWR VPWR sky130_fd_sc_hd__decap_3
XFILLER_13_387 VGND VGND VPWR VPWR sky130_fd_sc_hd__decap_3
XFILLER_40_195 VGND VGND VPWR VPWR sky130_fd_sc_hd__fill_1
XFILLER_9_358 VGND VGND VPWR VPWR sky130_fd_sc_hd__fill_1
XTAP_TAPCELL_ROW_97_1421 VGND VPWR sky130_fd_sc_hd__tapvpwrvgnd_1
XTAP_TAPCELL_ROW_97_1410 VGND VPWR sky130_fd_sc_hd__tapvpwrvgnd_1
XFILLER_114_418 VGND VGND VPWR VPWR sky130_fd_sc_hd__fill_2
XFILLER_31_92 VGND VGND VPWR VPWR sky130_fd_sc_hd__fill_1
XFILLER_107_470 VGND VGND VPWR VPWR sky130_fd_sc_hd__decap_3
XFILLER_110_602 VGND VGND VPWR VPWR sky130_fd_sc_hd__decap_3
XFILLER_95_324 VGND VGND VPWR VPWR sky130_fd_sc_hd__decap_3
XFILLER_95_346 VGND VGND VPWR VPWR sky130_fd_sc_hd__decap_3
XFILLER_48_262 VGND VGND VPWR VPWR sky130_fd_sc_hd__decap_3
XFILLER_83_508 VGND VGND VPWR VPWR sky130_fd_sc_hd__decap_3
XFILLER_36_424 VGND VGND VPWR VPWR sky130_fd_sc_hd__fill_1
XFILLER_36_446 VGND VGND VPWR VPWR sky130_fd_sc_hd__decap_3
XFILLER_63_232 VGND VGND VPWR VPWR sky130_fd_sc_hd__decap_3
XFILLER_51_405 VGND VGND VPWR VPWR sky130_fd_sc_hd__decap_3
XFILLER_63_287 VGND VGND VPWR VPWR sky130_fd_sc_hd__decap_3
X_4981_ _6992_/Q _5001_/A VGND VGND VPWR VPWR _6992_/D sky130_fd_sc_hd__xor2_2
XFILLER_16_192 VGND VGND VPWR VPWR sky130_fd_sc_hd__decap_3
XFILLER_51_449 VGND VGND VPWR VPWR sky130_fd_sc_hd__decap_3
Xclkbuf_leaf_43_clk clkbuf_leaf_1_clk/A VGND VGND VPWR VPWR clkload8/A sky130_fd_sc_hd__clkbuf_16
Xplace298 _3889_/A2 VGND VGND VPWR VPWR _3913_/A2 sky130_fd_sc_hd__buf_2
Xplace287 _3925_/A2 VGND VGND VPWR VPWR _3863_/A2 sky130_fd_sc_hd__buf_2
Xplace276 _3852_/B1 VGND VGND VPWR VPWR _3847_/B1 sky130_fd_sc_hd__buf_2
Xplace265 _5658_/D VGND VGND VPWR VPWR _5117_/B sky130_fd_sc_hd__buf_2
X_6720_ clkload1/A _6720_/D VGND VGND VPWR VPWR _6720_/Q sky130_fd_sc_hd__dfxtp_2
XTAP_TAPCELL_ROW_34_658 VGND VPWR sky130_fd_sc_hd__tapvpwrvgnd_1
XFILLER_31_140 VGND VGND VPWR VPWR sky130_fd_sc_hd__decap_3
X_6651_ _6651_/A VGND VGND VPWR VPWR _6651_/Y sky130_fd_sc_hd__inv_2
X_3863_ _6697_/Q _3863_/A2 _3925_/B1 _6875_/Q _3862_/X VGND VGND VPWR VPWR _3863_/X
+ sky130_fd_sc_hd__a221o_2
XFILLER_31_162 VGND VGND VPWR VPWR sky130_fd_sc_hd__fill_2
X_6582_ _6675_/A VGND VGND VPWR VPWR _6582_/Y sky130_fd_sc_hd__inv_2
X_5602_ _5602_/A _5611_/B VGND VGND VPWR VPWR _7026_/D sky130_fd_sc_hd__and2_2
X_3794_ _6774_/Q _3890_/A2 _3882_/A2 _6762_/Q _3793_/X VGND VGND VPWR VPWR _3794_/X
+ sky130_fd_sc_hd__a221o_2
XFILLER_105_429 VGND VGND VPWR VPWR sky130_fd_sc_hd__decap_3
X_7203_ _7361_/CLK _7203_/D _6483_/Y VGND VGND VPWR VPWR _7203_/Q sky130_fd_sc_hd__dfrtp_2
X_4415_ _7400_/Q _4419_/B1 _4434_/B1 _7144_/Q _4414_/X VGND VGND VPWR VPWR _4415_/X
+ sky130_fd_sc_hd__a221o_2
X_7134_ _7396_/CLK _7134_/D _6414_/Y VGND VGND VPWR VPWR _7134_/Q sky130_fd_sc_hd__dfrtp_2
X_4346_ _7321_/Q _4471_/S _3380_/Y _7353_/Q VGND VGND VPWR VPWR _4346_/X sky130_fd_sc_hd__a22o_2
XFILLER_101_613 VGND VGND VPWR VPWR sky130_fd_sc_hd__decap_3
XFILLER_59_505 VGND VGND VPWR VPWR sky130_fd_sc_hd__decap_3
XFILLER_59_527 VGND VGND VPWR VPWR sky130_fd_sc_hd__decap_3
XTAP_TAPCELL_ROW_6_328 VGND VPWR sky130_fd_sc_hd__tapvpwrvgnd_1
XFILLER_100_123 VGND VGND VPWR VPWR sky130_fd_sc_hd__decap_3
XFILLER_101_635 VGND VGND VPWR VPWR sky130_fd_sc_hd__decap_3
XFILLER_86_357 VGND VGND VPWR VPWR sky130_fd_sc_hd__decap_3
X_7065_ _7258_/CLK _7065_/D _6345_/Y VGND VGND VPWR VPWR _7065_/Q sky130_fd_sc_hd__dfrtp_2
X_4277_ _5003_/A _4620_/C VGND VGND VPWR VPWR _4277_/Y sky130_fd_sc_hd__nor2_2
XFILLER_98_195 VGND VGND VPWR VPWR sky130_fd_sc_hd__fill_1
XFILLER_100_156 VGND VGND VPWR VPWR sky130_fd_sc_hd__decap_3
XFILLER_74_508 VGND VGND VPWR VPWR sky130_fd_sc_hd__decap_3
XFILLER_86_368 VGND VGND VPWR VPWR sky130_fd_sc_hd__decap_3
XFILLER_100_189 VGND VGND VPWR VPWR sky130_fd_sc_hd__decap_3
XFILLER_27_413 VGND VGND VPWR VPWR sky130_fd_sc_hd__fill_1
XFILLER_36_15 VGND VGND VPWR VPWR sky130_fd_sc_hd__fill_1
XFILLER_36_26 VGND VGND VPWR VPWR sky130_fd_sc_hd__fill_2
XFILLER_54_221 VGND VGND VPWR VPWR sky130_fd_sc_hd__decap_3
XFILLER_67_582 VGND VGND VPWR VPWR sky130_fd_sc_hd__decap_3
XFILLER_82_530 VGND VGND VPWR VPWR sky130_fd_sc_hd__fill_2
XFILLER_36_59 VGND VGND VPWR VPWR sky130_fd_sc_hd__decap_3
XFILLER_42_416 VGND VGND VPWR VPWR sky130_fd_sc_hd__decap_3
XFILLER_54_265 VGND VGND VPWR VPWR sky130_fd_sc_hd__decap_3
XFILLER_54_287 VGND VGND VPWR VPWR sky130_fd_sc_hd__decap_3
XFILLER_82_574 VGND VGND VPWR VPWR sky130_fd_sc_hd__decap_3
XTAP_TAPCELL_ROW_68_1066 VGND VPWR sky130_fd_sc_hd__tapvpwrvgnd_1
Xclkbuf_leaf_34_clk clkbuf_3_2__f_clk/X VGND VGND VPWR VPWR _6972_/CLK sky130_fd_sc_hd__clkbuf_16
X_6918_ _7383_/CLK _6918_/D VGND VGND VPWR VPWR _6918_/Q sky130_fd_sc_hd__dfxtp_2
XTAP_TAPCELL_ROW_81_1222 VGND VPWR sky130_fd_sc_hd__tapvpwrvgnd_1
XFILLER_50_460 VGND VGND VPWR VPWR sky130_fd_sc_hd__decap_3
X_6849_ _6936_/CLK _6849_/D VGND VGND VPWR VPWR _6849_/Q sky130_fd_sc_hd__dfxtp_2
XFILLER_10_324 VGND VGND VPWR VPWR sky130_fd_sc_hd__decap_3
XFILLER_22_162 VGND VGND VPWR VPWR sky130_fd_sc_hd__decap_3
XFILLER_10_357 VGND VGND VPWR VPWR sky130_fd_sc_hd__decap_3
XFILLER_10_368 VGND VGND VPWR VPWR sky130_fd_sc_hd__decap_3
XFILLER_22_195 VGND VGND VPWR VPWR sky130_fd_sc_hd__fill_1
XFILLER_6_306 VGND VGND VPWR VPWR sky130_fd_sc_hd__fill_2
XFILLER_108_223 VGND VGND VPWR VPWR sky130_fd_sc_hd__decap_3
XFILLER_6_328 VGND VGND VPWR VPWR sky130_fd_sc_hd__fill_2
XFILLER_108_278 VGND VGND VPWR VPWR sky130_fd_sc_hd__fill_1
XTAP_TAPCELL_ROW_79_1195 VGND VPWR sky130_fd_sc_hd__tapvpwrvgnd_1
XFILLER_7_3 VGND VGND VPWR VPWR sky130_fd_sc_hd__decap_3
XTAP_TAPCELL_ROW_92_1351 VGND VPWR sky130_fd_sc_hd__tapvpwrvgnd_1
XFILLER_104_451 VGND VGND VPWR VPWR sky130_fd_sc_hd__decap_3
XFILLER_77_55 VGND VGND VPWR VPWR sky130_fd_sc_hd__fill_1
XFILLER_89_151 VGND VGND VPWR VPWR sky130_fd_sc_hd__decap_3
XFILLER_77_346 VGND VGND VPWR VPWR sky130_fd_sc_hd__decap_3
XFILLER_77_66 VGND VGND VPWR VPWR sky130_fd_sc_hd__decap_3
XFILLER_65_508 VGND VGND VPWR VPWR sky130_fd_sc_hd__decap_3
XFILLER_18_424 VGND VGND VPWR VPWR sky130_fd_sc_hd__fill_2
XFILLER_92_327 VGND VGND VPWR VPWR sky130_fd_sc_hd__decap_3
XFILLER_92_349 VGND VGND VPWR VPWR sky130_fd_sc_hd__decap_3
XFILLER_73_541 VGND VGND VPWR VPWR sky130_fd_sc_hd__fill_2
XFILLER_73_552 VGND VGND VPWR VPWR sky130_fd_sc_hd__decap_3
XFILLER_93_43 VGND VGND VPWR VPWR sky130_fd_sc_hd__decap_3
Xhold1080 _7278_/Q VGND VGND VPWR VPWR _4718_/A0 sky130_fd_sc_hd__dlygate4sd3_1
Xhold1091 _7341_/Q VGND VGND VPWR VPWR _4476_/A0 sky130_fd_sc_hd__dlygate4sd3_1
XFILLER_93_76 VGND VGND VPWR VPWR sky130_fd_sc_hd__decap_3
XFILLER_26_70 VGND VGND VPWR VPWR sky130_fd_sc_hd__decap_3
XFILLER_26_92 VGND VGND VPWR VPWR sky130_fd_sc_hd__decap_3
XFILLER_33_449 VGND VGND VPWR VPWR sky130_fd_sc_hd__decap_3
XFILLER_60_235 VGND VGND VPWR VPWR sky130_fd_sc_hd__decap_3
Xclkbuf_leaf_25_clk clkbuf_3_3__f_clk/X VGND VGND VPWR VPWR _6966_/CLK sky130_fd_sc_hd__clkbuf_16
XFILLER_13_140 VGND VGND VPWR VPWR sky130_fd_sc_hd__fill_2
XFILLER_41_460 VGND VGND VPWR VPWR sky130_fd_sc_hd__decap_3
XFILLER_13_184 VGND VGND VPWR VPWR sky130_fd_sc_hd__decap_3
XTAP_TAPCELL_ROW_31_628 VGND VPWR sky130_fd_sc_hd__tapvpwrvgnd_1
XFILLER_9_122 VGND VGND VPWR VPWR sky130_fd_sc_hd__decap_3
XFILLER_9_155 VGND VGND VPWR VPWR sky130_fd_sc_hd__decap_3
XFILLER_42_91 VGND VGND VPWR VPWR sky130_fd_sc_hd__decap_3
XFILLER_9_199 VGND VGND VPWR VPWR sky130_fd_sc_hd__decap_3
XFILLER_61_6 VGND VGND VPWR VPWR sky130_fd_sc_hd__decap_3
XTAP_TAPCELL_ROW_11_385 VGND VPWR sky130_fd_sc_hd__tapvpwrvgnd_1
XFILLER_5_361 VGND VGND VPWR VPWR sky130_fd_sc_hd__decap_3
X_4200_ _4950_/A _4381_/A VGND VGND VPWR VPWR _4200_/X sky130_fd_sc_hd__or2_2
XFILLER_96_622 VGND VGND VPWR VPWR sky130_fd_sc_hd__decap_3
XFILLER_110_410 VGND VGND VPWR VPWR sky130_fd_sc_hd__decap_3
XFILLER_110_421 VGND VGND VPWR VPWR sky130_fd_sc_hd__decap_3
XFILLER_3_41 VGND VGND VPWR VPWR sky130_fd_sc_hd__fill_2
XFILLER_68_324 VGND VGND VPWR VPWR sky130_fd_sc_hd__decap_3
XFILLER_95_110 VGND VGND VPWR VPWR sky130_fd_sc_hd__fill_2
XFILLER_95_121 VGND VGND VPWR VPWR sky130_fd_sc_hd__decap_3
X_4131_ _7267_/Q _4418_/A2 _4128_/X _4130_/X VGND VGND VPWR VPWR _4131_/X sky130_fd_sc_hd__a211o_2
XFILLER_110_454 VGND VGND VPWR VPWR sky130_fd_sc_hd__decap_3
XFILLER_68_368 VGND VGND VPWR VPWR sky130_fd_sc_hd__decap_3
XFILLER_95_154 VGND VGND VPWR VPWR sky130_fd_sc_hd__decap_3
X_4062_ _7026_/Q _4437_/A2 _3945_/S _7212_/Q _4061_/X VGND VGND VPWR VPWR _4062_/X
+ sky130_fd_sc_hd__a221o_2
XTAP_TAPCELL_ROW_39_717 VGND VPWR sky130_fd_sc_hd__tapvpwrvgnd_1
XFILLER_36_210 VGND VGND VPWR VPWR sky130_fd_sc_hd__decap_3
XFILLER_83_327 VGND VGND VPWR VPWR sky130_fd_sc_hd__decap_3
XFILLER_95_187 VGND VGND VPWR VPWR sky130_fd_sc_hd__decap_3
XFILLER_36_276 VGND VGND VPWR VPWR sky130_fd_sc_hd__decap_3
XFILLER_64_563 VGND VGND VPWR VPWR sky130_fd_sc_hd__decap_3
XFILLER_64_596 VGND VGND VPWR VPWR sky130_fd_sc_hd__decap_3
XTAP_TAPCELL_ROW_19_474 VGND VPWR sky130_fd_sc_hd__tapvpwrvgnd_1
XFILLER_91_382 VGND VGND VPWR VPWR sky130_fd_sc_hd__fill_2
XFILLER_91_393 VGND VGND VPWR VPWR sky130_fd_sc_hd__decap_3
Xclkbuf_leaf_16_clk clkload0/A VGND VGND VPWR VPWR _7403_/CLK sky130_fd_sc_hd__clkbuf_16
X_4964_ _5092_/C _4961_/X _6994_/D _4997_/A1 VGND VGND VPWR VPWR _4964_/X sky130_fd_sc_hd__a22o_2
XTAP_TAPCELL_ROW_19_485 VGND VPWR sky130_fd_sc_hd__tapvpwrvgnd_1
X_6703_ _7384_/CLK _6703_/D VGND VGND VPWR VPWR _6703_/Q sky130_fd_sc_hd__dfxtp_2
X_3915_ _3915_/A0 _3914_/X _5138_/S VGND VGND VPWR VPWR _7378_/D sky130_fd_sc_hd__mux2_2
X_4895_ _6997_/Q _5605_/B _4909_/B VGND VGND VPWR VPWR _4896_/B sky130_fd_sc_hd__a21o_2
X_6634_ _6634_/A VGND VGND VPWR VPWR _6634_/Y sky130_fd_sc_hd__inv_2
X_3846_ _6964_/Q _3852_/A2 _3853_/A2 _6952_/Q VGND VGND VPWR VPWR _3846_/X sky130_fd_sc_hd__a22o_2
X_6565_ _6599_/A VGND VGND VPWR VPWR _6565_/Y sky130_fd_sc_hd__inv_2
X_3777_ _6972_/Q _3656_/Y _3847_/B1 _6722_/Q _3776_/X VGND VGND VPWR VPWR _3777_/X
+ sky130_fd_sc_hd__a221o_2
X_6496_ _6562_/A VGND VGND VPWR VPWR _6496_/Y sky130_fd_sc_hd__inv_2
XTAP_TAPCELL_ROW_115_1627 VGND VPWR sky130_fd_sc_hd__tapvpwrvgnd_1
XFILLER_105_248 VGND VGND VPWR VPWR sky130_fd_sc_hd__decap_3
XFILLER_59_302 VGND VGND VPWR VPWR sky130_fd_sc_hd__decap_3
Xoutput496 _5658_/C VGND VGND VPWR VPWR alu_result_out[9] sky130_fd_sc_hd__clkdlybuf4s25_1
Xoutput485 _5663_/A VGND VGND VPWR VPWR alu_result_out[28] sky130_fd_sc_hd__clkdlybuf4s25_1
Xoutput474 _5657_/C VGND VGND VPWR VPWR alu_result_out[18] sky130_fd_sc_hd__clkdlybuf4s25_1
XFILLER_101_421 VGND VGND VPWR VPWR sky130_fd_sc_hd__decap_3
XFILLER_113_281 VGND VGND VPWR VPWR sky130_fd_sc_hd__decap_3
XFILLER_59_346 VGND VGND VPWR VPWR sky130_fd_sc_hd__decap_3
XFILLER_86_121 VGND VGND VPWR VPWR sky130_fd_sc_hd__decap_3
X_7117_ _7340_/CLK _7117_/D _6397_/Y VGND VGND VPWR VPWR _7117_/Q sky130_fd_sc_hd__dfrtp_2
X_4329_ _4362_/C _4362_/A _4362_/B VGND VGND VPWR VPWR _4330_/B sky130_fd_sc_hd__and3b_2
XFILLER_99_482 VGND VGND VPWR VPWR sky130_fd_sc_hd__decap_3
XFILLER_47_36 VGND VGND VPWR VPWR sky130_fd_sc_hd__decap_3
XFILLER_74_305 VGND VGND VPWR VPWR sky130_fd_sc_hd__decap_3
XFILLER_87_677 VGND VGND VPWR VPWR sky130_fd_sc_hd__decap_3
X_7048_ _7403_/CLK _7048_/D _6328_/Y VGND VGND VPWR VPWR _7048_/Q sky130_fd_sc_hd__dfrtp_2
XPHY_EDGE_ROW_114_Right_114 VGND VGND VPWR VPWR sky130_fd_sc_hd__decap_3
XFILLER_27_221 VGND VGND VPWR VPWR sky130_fd_sc_hd__decap_3
XFILLER_27_243 VGND VGND VPWR VPWR sky130_fd_sc_hd__decap_3
XFILLER_55_552 VGND VGND VPWR VPWR sky130_fd_sc_hd__decap_3
XFILLER_103_75 VGND VGND VPWR VPWR sky130_fd_sc_hd__fill_2
XFILLER_70_511 VGND VGND VPWR VPWR sky130_fd_sc_hd__decap_3
XFILLER_103_97 VGND VGND VPWR VPWR sky130_fd_sc_hd__decap_3
XFILLER_42_246 VGND VGND VPWR VPWR sky130_fd_sc_hd__decap_3
XFILLER_63_57 VGND VGND VPWR VPWR sky130_fd_sc_hd__decap_3
XFILLER_70_533 VGND VGND VPWR VPWR sky130_fd_sc_hd__decap_3
XFILLER_82_382 VGND VGND VPWR VPWR sky130_fd_sc_hd__decap_3
XFILLER_70_577 VGND VGND VPWR VPWR sky130_fd_sc_hd__decap_3
XFILLER_10_121 VGND VGND VPWR VPWR sky130_fd_sc_hd__decap_3
XFILLER_109_532 VGND VGND VPWR VPWR sky130_fd_sc_hd__decap_3
XFILLER_109_576 VGND VGND VPWR VPWR sky130_fd_sc_hd__fill_1
XFILLER_12_50 VGND VGND VPWR VPWR sky130_fd_sc_hd__decap_3
XFILLER_6_147 VGND VGND VPWR VPWR sky130_fd_sc_hd__fill_2
XFILLER_6_158 VGND VGND VPWR VPWR sky130_fd_sc_hd__decap_3
Xwire568 _3576_/Y VGND VGND VPWR VPWR _3591_/B sky130_fd_sc_hd__clkbuf_2
Xwire579 wire579/A VGND VGND VPWR VPWR _6536_/A sky130_fd_sc_hd__buf_2
XFILLER_97_408 VGND VGND VPWR VPWR sky130_fd_sc_hd__decap_3
XFILLER_88_76 VGND VGND VPWR VPWR sky130_fd_sc_hd__fill_1
XFILLER_77_110 VGND VGND VPWR VPWR sky130_fd_sc_hd__fill_2
XFILLER_78_622 VGND VGND VPWR VPWR sky130_fd_sc_hd__decap_3
XFILLER_26_9 VGND VGND VPWR VPWR sky130_fd_sc_hd__decap_3
XFILLER_77_132 VGND VGND VPWR VPWR sky130_fd_sc_hd__fill_1
XFILLER_93_603 VGND VGND VPWR VPWR sky130_fd_sc_hd__fill_2
XFILLER_65_316 VGND VGND VPWR VPWR sky130_fd_sc_hd__decap_3
XFILLER_92_124 VGND VGND VPWR VPWR sky130_fd_sc_hd__decap_3
XFILLER_18_221 VGND VGND VPWR VPWR sky130_fd_sc_hd__decap_3
XFILLER_18_265 VGND VGND VPWR VPWR sky130_fd_sc_hd__decap_3
XFILLER_33_202 VGND VGND VPWR VPWR sky130_fd_sc_hd__decap_3
XFILLER_46_585 VGND VGND VPWR VPWR sky130_fd_sc_hd__decap_3
XFILLER_61_511 VGND VGND VPWR VPWR sky130_fd_sc_hd__decap_3
XFILLER_73_371 VGND VGND VPWR VPWR sky130_fd_sc_hd__decap_3
XFILLER_92_179 VGND VGND VPWR VPWR sky130_fd_sc_hd__decap_3
XFILLER_18_298 VGND VGND VPWR VPWR sky130_fd_sc_hd__fill_2
XFILLER_33_257 VGND VGND VPWR VPWR sky130_fd_sc_hd__decap_3
XFILLER_61_555 VGND VGND VPWR VPWR sky130_fd_sc_hd__decap_3
XTAP_TAPCELL_ROW_44_775 VGND VPWR sky130_fd_sc_hd__tapvpwrvgnd_1
XTAP_TAPCELL_ROW_16_444 VGND VPWR sky130_fd_sc_hd__tapvpwrvgnd_1
XFILLER_53_90 VGND VGND VPWR VPWR sky130_fd_sc_hd__decap_3
X_3700_ _6939_/Q _3828_/A2 _3825_/B1 _6803_/Q _3699_/X VGND VGND VPWR VPWR _3700_/X
+ sky130_fd_sc_hd__a221o_2
XFILLER_41_290 VGND VGND VPWR VPWR sky130_fd_sc_hd__decap_3
X_4680_ _4680_/A _5015_/B VGND VGND VPWR VPWR _5009_/A sky130_fd_sc_hd__nor2_2
X_3631_ _3630_/A _3630_/B _5103_/A1 VGND VGND VPWR VPWR _3631_/Y sky130_fd_sc_hd__o21ai_2
X_6350_ _6540_/A VGND VGND VPWR VPWR _6350_/Y sky130_fd_sc_hd__inv_2
X_3562_ _3562_/A _3562_/B _3561_/X VGND VGND VPWR VPWR _5362_/C sky130_fd_sc_hd__or3b_2
X_6281_ _6288_/A VGND VGND VPWR VPWR _6281_/Y sky130_fd_sc_hd__inv_2
X_3493_ _7087_/Q _4351_/A2 _3407_/X _7119_/Q VGND VGND VPWR VPWR _3493_/X sky130_fd_sc_hd__a22o_2
XFILLER_88_419 VGND VGND VPWR VPWR sky130_fd_sc_hd__fill_1
Xclkbuf_leaf_5_clk clkbuf_leaf_7_clk/A VGND VGND VPWR VPWR _7362_/CLK sky130_fd_sc_hd__clkbuf_16
X_5232_ _5232_/A0 _4716_/X _5245_/S VGND VGND VPWR VPWR _7214_/D sky130_fd_sc_hd__mux2_2
XFILLER_102_229 VGND VGND VPWR VPWR sky130_fd_sc_hd__decap_3
XFILLER_68_110 VGND VGND VPWR VPWR sky130_fd_sc_hd__decap_3
XFILLER_96_430 VGND VGND VPWR VPWR sky130_fd_sc_hd__decap_3
X_5163_ _5163_/A _5190_/B VGND VGND VPWR VPWR _7246_/D sky130_fd_sc_hd__and2_2
XFILLER_110_251 VGND VGND VPWR VPWR sky130_fd_sc_hd__fill_1
XFILLER_29_508 VGND VGND VPWR VPWR sky130_fd_sc_hd__decap_3
X_4114_ _7172_/Q _3366_/X _4190_/B1 _7140_/Q _4113_/X VGND VGND VPWR VPWR _4114_/X
+ sky130_fd_sc_hd__a221o_2
XTAP_TAPCELL_ROW_110_1568 VGND VPWR sky130_fd_sc_hd__tapvpwrvgnd_1
XFILLER_56_327 VGND VGND VPWR VPWR sky130_fd_sc_hd__decap_3
XFILLER_68_176 VGND VGND VPWR VPWR sky130_fd_sc_hd__decap_3
XFILLER_84_636 VGND VGND VPWR VPWR sky130_fd_sc_hd__decap_3
XFILLER_96_474 VGND VGND VPWR VPWR sky130_fd_sc_hd__fill_2
X_5094_ _5666_/A _6986_/D _5093_/X VGND VGND VPWR VPWR _5094_/X sky130_fd_sc_hd__a21o_2
XFILLER_110_295 VGND VGND VPWR VPWR sky130_fd_sc_hd__fill_1
X_4045_ _7085_/Q _4432_/A2 _4432_/B1 _4044_/X VGND VGND VPWR VPWR _4054_/A sky130_fd_sc_hd__o211a_2
XFILLER_17_39 VGND VGND VPWR VPWR sky130_fd_sc_hd__decap_3
XFILLER_64_371 VGND VGND VPWR VPWR sky130_fd_sc_hd__decap_3
XFILLER_24_224 VGND VGND VPWR VPWR sky130_fd_sc_hd__decap_3
XFILLER_52_533 VGND VGND VPWR VPWR sky130_fd_sc_hd__fill_2
XTAP_TAPCELL_ROW_65_1036 VGND VPWR sky130_fd_sc_hd__tapvpwrvgnd_1
XFILLER_12_419 VGND VGND VPWR VPWR sky130_fd_sc_hd__fill_1
X_4878_ _4997_/A1 _6999_/D _4870_/Y _4877_/X VGND VGND VPWR VPWR _4878_/X sky130_fd_sc_hd__a211o_2
XFILLER_20_474 VGND VGND VPWR VPWR sky130_fd_sc_hd__fill_2
X_6617_ _6617_/A VGND VGND VPWR VPWR _6617_/Y sky130_fd_sc_hd__inv_2
X_3829_ _6908_/Q _3869_/A2 _3912_/B1 _6900_/Q VGND VGND VPWR VPWR _3829_/X sky130_fd_sc_hd__a22o_2
X_6548_ _6548_/A VGND VGND VPWR VPWR _6548_/Y sky130_fd_sc_hd__inv_2
XFILLER_109_6 VGND VGND VPWR VPWR sky130_fd_sc_hd__decap_3
X_6479_ _6642_/A VGND VGND VPWR VPWR _6479_/Y sky130_fd_sc_hd__inv_2
XTAP_TAPCELL_ROW_76_1165 VGND VPWR sky130_fd_sc_hd__tapvpwrvgnd_1
XFILLER_106_579 VGND VGND VPWR VPWR sky130_fd_sc_hd__fill_1
XFILLER_79_408 VGND VGND VPWR VPWR sky130_fd_sc_hd__decap_3
XFILLER_58_24 VGND VGND VPWR VPWR sky130_fd_sc_hd__decap_3
XFILLER_58_35 VGND VGND VPWR VPWR sky130_fd_sc_hd__decap_3
XFILLER_99_290 VGND VGND VPWR VPWR sky130_fd_sc_hd__decap_3
XFILLER_101_240 VGND VGND VPWR VPWR sky130_fd_sc_hd__decap_3
XFILLER_59_143 VGND VGND VPWR VPWR sky130_fd_sc_hd__decap_3
XFILLER_75_603 VGND VGND VPWR VPWR sky130_fd_sc_hd__decap_3
XFILLER_101_251 VGND VGND VPWR VPWR sky130_fd_sc_hd__decap_3
XFILLER_47_305 VGND VGND VPWR VPWR sky130_fd_sc_hd__decap_3
XFILLER_59_165 VGND VGND VPWR VPWR sky130_fd_sc_hd__decap_3
XFILLER_114_74 VGND VGND VPWR VPWR sky130_fd_sc_hd__decap_3
XFILLER_114_85 VGND VGND VPWR VPWR sky130_fd_sc_hd__decap_3
XFILLER_47_349 VGND VGND VPWR VPWR sky130_fd_sc_hd__fill_1
XFILLER_74_124 VGND VGND VPWR VPWR sky130_fd_sc_hd__fill_2
XFILLER_74_168 VGND VGND VPWR VPWR sky130_fd_sc_hd__decap_3
XFILLER_74_56 VGND VGND VPWR VPWR sky130_fd_sc_hd__decap_3
XFILLER_90_639 VGND VGND VPWR VPWR sky130_fd_sc_hd__decap_3
XFILLER_55_382 VGND VGND VPWR VPWR sky130_fd_sc_hd__fill_2
XTAP_TAPCELL_ROW_87_1294 VGND VPWR sky130_fd_sc_hd__tapvpwrvgnd_1
XFILLER_15_246 VGND VGND VPWR VPWR sky130_fd_sc_hd__decap_3
XFILLER_43_555 VGND VGND VPWR VPWR sky130_fd_sc_hd__decap_3
XFILLER_70_341 VGND VGND VPWR VPWR sky130_fd_sc_hd__decap_3
XFILLER_90_11 VGND VGND VPWR VPWR sky130_fd_sc_hd__decap_3
XFILLER_30_205 VGND VGND VPWR VPWR sky130_fd_sc_hd__decap_3
XFILLER_70_374 VGND VGND VPWR VPWR sky130_fd_sc_hd__decap_3
XFILLER_90_44 VGND VGND VPWR VPWR sky130_fd_sc_hd__decap_3
XTAP_TAPCELL_ROW_13_403 VGND VPWR sky130_fd_sc_hd__tapvpwrvgnd_1
XFILLER_30_249 VGND VGND VPWR VPWR sky130_fd_sc_hd__decap_3
XFILLER_90_77 VGND VGND VPWR VPWR sky130_fd_sc_hd__fill_1
XFILLER_90_88 VGND VGND VPWR VPWR sky130_fd_sc_hd__decap_3
XTAP_TAPCELL_ROW_41_745 VGND VPWR sky130_fd_sc_hd__tapvpwrvgnd_1
XFILLER_11_463 VGND VGND VPWR VPWR sky130_fd_sc_hd__decap_3
XFILLER_23_60 VGND VGND VPWR VPWR sky130_fd_sc_hd__decap_3
XFILLER_109_340 VGND VGND VPWR VPWR sky130_fd_sc_hd__decap_3
XFILLER_7_445 VGND VGND VPWR VPWR sky130_fd_sc_hd__decap_3
XFILLER_109_373 VGND VGND VPWR VPWR sky130_fd_sc_hd__decap_3
XFILLER_112_516 VGND VGND VPWR VPWR sky130_fd_sc_hd__decap_3
XFILLER_3_673 VGND VGND VPWR VPWR sky130_fd_sc_hd__fill_2
XFILLER_112_549 VGND VGND VPWR VPWR sky130_fd_sc_hd__decap_3
XFILLER_97_249 VGND VGND VPWR VPWR sky130_fd_sc_hd__decap_3
XFILLER_78_452 VGND VGND VPWR VPWR sky130_fd_sc_hd__decap_3
XFILLER_38_305 VGND VGND VPWR VPWR sky130_fd_sc_hd__decap_3
XFILLER_65_113 VGND VGND VPWR VPWR sky130_fd_sc_hd__decap_3
XFILLER_93_411 VGND VGND VPWR VPWR sky130_fd_sc_hd__decap_3
XTAP_TAPCELL_ROW_49_834 VGND VPWR sky130_fd_sc_hd__tapvpwrvgnd_1
XFILLER_38_338 VGND VGND VPWR VPWR sky130_fd_sc_hd__decap_3
XFILLER_81_606 VGND VGND VPWR VPWR sky130_fd_sc_hd__decap_3
XFILLER_93_455 VGND VGND VPWR VPWR sky130_fd_sc_hd__fill_1
Xsingle_cycle_cpu_586 VGND VGND VPWR VPWR instruction_out[1] single_cycle_cpu_586/LO
+ sky130_fd_sc_hd__conb_1
XTAP_TAPCELL_ROW_49_845 VGND VPWR sky130_fd_sc_hd__tapvpwrvgnd_1
XFILLER_0_53 VGND VGND VPWR VPWR sky130_fd_sc_hd__decap_3
XFILLER_19_574 VGND VGND VPWR VPWR sky130_fd_sc_hd__fill_2
XFILLER_46_360 VGND VGND VPWR VPWR sky130_fd_sc_hd__decap_3
XFILLER_53_308 VGND VGND VPWR VPWR sky130_fd_sc_hd__decap_3
XFILLER_81_617 VGND VGND VPWR VPWR sky130_fd_sc_hd__decap_3
XFILLER_93_499 VGND VGND VPWR VPWR sky130_fd_sc_hd__decap_3
XFILLER_0_75 VGND VGND VPWR VPWR sky130_fd_sc_hd__decap_3
XFILLER_34_511 VGND VGND VPWR VPWR sky130_fd_sc_hd__decap_3
XFILLER_34_533 VGND VGND VPWR VPWR sky130_fd_sc_hd__fill_2
XFILLER_46_371 VGND VGND VPWR VPWR sky130_fd_sc_hd__decap_3
XFILLER_80_116 VGND VGND VPWR VPWR sky130_fd_sc_hd__decap_3
XFILLER_61_330 VGND VGND VPWR VPWR sky130_fd_sc_hd__decap_3
XFILLER_61_352 VGND VGND VPWR VPWR sky130_fd_sc_hd__decap_3
XFILLER_73_190 VGND VGND VPWR VPWR sky130_fd_sc_hd__decap_3
XFILLER_21_205 VGND VGND VPWR VPWR sky130_fd_sc_hd__decap_3
XFILLER_21_216 VGND VGND VPWR VPWR sky130_fd_sc_hd__decap_3
XFILLER_61_396 VGND VGND VPWR VPWR sky130_fd_sc_hd__decap_3
X_4801_ _4801_/A _4801_/B VGND VGND VPWR VPWR _7003_/D sky130_fd_sc_hd__nor2_2
XFILLER_14_290 VGND VGND VPWR VPWR sky130_fd_sc_hd__decap_3
XFILLER_21_249 VGND VGND VPWR VPWR sky130_fd_sc_hd__decap_3
X_4663_ _4764_/B _4040_/B _4608_/Y _4659_/X _4662_/Y VGND VGND VPWR VPWR _5665_/A
+ sky130_fd_sc_hd__o32a_2
X_6402_ _6532_/A VGND VGND VPWR VPWR _6402_/Y sky130_fd_sc_hd__inv_2
X_3614_ _3614_/A _3614_/B VGND VGND VPWR VPWR _3746_/B sky130_fd_sc_hd__and2_2
X_7382_ clkload3/A _7382_/D _6662_/Y VGND VGND VPWR VPWR _7382_/Q sky130_fd_sc_hd__dfrtp_2
Xhold902 _7110_/Q VGND VGND VPWR VPWR _7110_/D sky130_fd_sc_hd__dlygate4sd3_1
Xhold913 _6687_/Q VGND VGND VPWR VPWR hold913/X sky130_fd_sc_hd__dlygate4sd3_1
XFILLER_115_332 VGND VGND VPWR VPWR sky130_fd_sc_hd__decap_3
Xhold924 _7014_/Q VGND VGND VPWR VPWR _5628_/A sky130_fd_sc_hd__dlygate4sd3_1
Xhold935 _7025_/Q VGND VGND VPWR VPWR _5605_/A sky130_fd_sc_hd__dlygate4sd3_1
Xhold946 _7311_/Q VGND VGND VPWR VPWR hold946/X sky130_fd_sc_hd__dlygate4sd3_1
X_6333_ _6682_/A VGND VGND VPWR VPWR _6333_/Y sky130_fd_sc_hd__inv_2
X_3545_ _3545_/A _3545_/B VGND VGND VPWR VPWR _3636_/A sky130_fd_sc_hd__nor2_2
Xhold979 _7015_/Q VGND VGND VPWR VPWR _5626_/A sky130_fd_sc_hd__dlygate4sd3_1
Xhold968 _6694_/Q VGND VGND VPWR VPWR hold968/X sky130_fd_sc_hd__dlygate4sd3_1
Xhold957 _7018_/Q VGND VGND VPWR VPWR _5619_/A sky130_fd_sc_hd__dlygate4sd3_1
X_6264_ _6642_/A VGND VGND VPWR VPWR _6264_/Y sky130_fd_sc_hd__inv_2
X_3476_ _7056_/Q _3577_/B _3590_/A VGND VGND VPWR VPWR _3502_/B sky130_fd_sc_hd__o21ai_2
XFILLER_115_387 VGND VGND VPWR VPWR sky130_fd_sc_hd__decap_3
X_5215_ _7221_/Q _5225_/B VGND VGND VPWR VPWR _7221_/D sky130_fd_sc_hd__and2_2
XFILLER_57_603 VGND VGND VPWR VPWR sky130_fd_sc_hd__decap_3
XFILLER_69_441 VGND VGND VPWR VPWR sky130_fd_sc_hd__decap_3
XFILLER_69_452 VGND VGND VPWR VPWR sky130_fd_sc_hd__decap_3
XFILLER_28_27 VGND VGND VPWR VPWR sky130_fd_sc_hd__fill_1
XFILLER_29_316 VGND VGND VPWR VPWR sky130_fd_sc_hd__decap_3
XFILLER_56_113 VGND VGND VPWR VPWR sky130_fd_sc_hd__decap_3
XFILLER_84_411 VGND VGND VPWR VPWR sky130_fd_sc_hd__decap_3
XFILLER_96_271 VGND VGND VPWR VPWR sky130_fd_sc_hd__decap_3
X_5146_ _5145_/A _3541_/X _4811_/C VGND VGND VPWR VPWR _5146_/Y sky130_fd_sc_hd__o21ai_2
X_5077_ _4799_/A _3863_/X _5658_/A VGND VGND VPWR VPWR _5077_/X sky130_fd_sc_hd__a21o_2
XFILLER_56_168 VGND VGND VPWR VPWR sky130_fd_sc_hd__decap_3
XFILLER_72_628 VGND VGND VPWR VPWR sky130_fd_sc_hd__fill_1
XFILLER_84_477 VGND VGND VPWR VPWR sky130_fd_sc_hd__decap_3
XFILLER_37_393 VGND VGND VPWR VPWR sky130_fd_sc_hd__decap_3
XFILLER_71_149 VGND VGND VPWR VPWR sky130_fd_sc_hd__decap_3
XFILLER_52_330 VGND VGND VPWR VPWR sky130_fd_sc_hd__decap_3
XFILLER_80_661 VGND VGND VPWR VPWR sky130_fd_sc_hd__decap_3
XFILLER_52_363 VGND VGND VPWR VPWR sky130_fd_sc_hd__fill_1
XFILLER_52_374 VGND VGND VPWR VPWR sky130_fd_sc_hd__decap_3
XFILLER_100_32 VGND VGND VPWR VPWR sky130_fd_sc_hd__decap_3
XFILLER_12_249 VGND VGND VPWR VPWR sky130_fd_sc_hd__decap_3
XFILLER_40_569 VGND VGND VPWR VPWR sky130_fd_sc_hd__fill_2
XFILLER_8_209 VGND VGND VPWR VPWR sky130_fd_sc_hd__decap_3
XFILLER_100_76 VGND VGND VPWR VPWR sky130_fd_sc_hd__fill_1
XFILLER_60_58 VGND VGND VPWR VPWR sky130_fd_sc_hd__decap_3
XFILLER_106_321 VGND VGND VPWR VPWR sky130_fd_sc_hd__decap_3
XFILLER_109_52 VGND VGND VPWR VPWR sky130_fd_sc_hd__decap_3
XFILLER_109_63 VGND VGND VPWR VPWR sky130_fd_sc_hd__decap_3
XFILLER_106_354 VGND VGND VPWR VPWR sky130_fd_sc_hd__decap_3
XFILLER_106_365 VGND VGND VPWR VPWR sky130_fd_sc_hd__fill_2
XFILLER_106_398 VGND VGND VPWR VPWR sky130_fd_sc_hd__fill_1
XFILLER_79_216 VGND VGND VPWR VPWR sky130_fd_sc_hd__decap_3
XFILLER_102_582 VGND VGND VPWR VPWR sky130_fd_sc_hd__decap_3
XFILLER_47_113 VGND VGND VPWR VPWR sky130_fd_sc_hd__decap_3
XFILLER_85_11 VGND VGND VPWR VPWR sky130_fd_sc_hd__decap_3
XFILLER_47_135 VGND VGND VPWR VPWR sky130_fd_sc_hd__decap_3
XFILLER_75_433 VGND VGND VPWR VPWR sky130_fd_sc_hd__decap_3
XFILLER_75_455 VGND VGND VPWR VPWR sky130_fd_sc_hd__decap_3
XFILLER_85_66 VGND VGND VPWR VPWR sky130_fd_sc_hd__decap_3
XFILLER_87_293 VGND VGND VPWR VPWR sky130_fd_sc_hd__decap_3
XTAP_TAPCELL_ROW_89_1323 VGND VPWR sky130_fd_sc_hd__tapvpwrvgnd_1
XFILLER_63_628 VGND VGND VPWR VPWR sky130_fd_sc_hd__decap_3
XFILLER_85_99 VGND VGND VPWR VPWR sky130_fd_sc_hd__decap_3
XTAP_TAPCELL_ROW_46_804 VGND VPWR sky130_fd_sc_hd__tapvpwrvgnd_1
XFILLER_16_533 VGND VGND VPWR VPWR sky130_fd_sc_hd__decap_3
XFILLER_28_371 VGND VGND VPWR VPWR sky130_fd_sc_hd__fill_1
XFILLER_43_330 VGND VGND VPWR VPWR sky130_fd_sc_hd__decap_3
XFILLER_71_650 VGND VGND VPWR VPWR sky130_fd_sc_hd__decap_3
XFILLER_90_458 VGND VGND VPWR VPWR sky130_fd_sc_hd__decap_3
XFILLER_31_514 VGND VGND VPWR VPWR sky130_fd_sc_hd__fill_1
XFILLER_31_536 VGND VGND VPWR VPWR sky130_fd_sc_hd__decap_3
XFILLER_43_374 VGND VGND VPWR VPWR sky130_fd_sc_hd__decap_3
XFILLER_70_160 VGND VGND VPWR VPWR sky130_fd_sc_hd__decap_3
XTAP_TAPCELL_ROW_26_561 VGND VPWR sky130_fd_sc_hd__tapvpwrvgnd_1
XFILLER_31_558 VGND VGND VPWR VPWR sky130_fd_sc_hd__fill_2
XFILLER_34_81 VGND VGND VPWR VPWR sky130_fd_sc_hd__decap_3
XFILLER_43_396 VGND VGND VPWR VPWR sky130_fd_sc_hd__fill_2
XFILLER_70_193 VGND VGND VPWR VPWR sky130_fd_sc_hd__decap_3
XFILLER_93_9 VGND VGND VPWR VPWR sky130_fd_sc_hd__decap_3
XFILLER_11_293 VGND VGND VPWR VPWR sky130_fd_sc_hd__decap_3
XFILLER_7_220 VGND VGND VPWR VPWR sky130_fd_sc_hd__decap_3
XFILLER_7_231 VGND VGND VPWR VPWR sky130_fd_sc_hd__decap_3
XFILLER_7_253 VGND VGND VPWR VPWR sky130_fd_sc_hd__decap_3
XFILLER_50_91 VGND VGND VPWR VPWR sky130_fd_sc_hd__decap_3
X_3330_ _3386_/A VGND VGND VPWR VPWR _3330_/Y sky130_fd_sc_hd__inv_2
XFILLER_112_302 VGND VGND VPWR VPWR sky130_fd_sc_hd__decap_3
XFILLER_112_335 VGND VGND VPWR VPWR sky130_fd_sc_hd__decap_3
XFILLER_98_536 VGND VGND VPWR VPWR sky130_fd_sc_hd__decap_3
XFILLER_98_525 VGND VGND VPWR VPWR sky130_fd_sc_hd__decap_3
XFILLER_112_368 VGND VGND VPWR VPWR sky130_fd_sc_hd__decap_3
X_5000_ _6991_/Q _5026_/A VGND VGND VPWR VPWR _5001_/B sky130_fd_sc_hd__nor2_2
XPHY_EDGE_ROW_0_Left_117 VGND VGND VPWR VPWR sky130_fd_sc_hd__decap_3
XFILLER_98_569 VGND VGND VPWR VPWR sky130_fd_sc_hd__decap_3
XFILLER_22_3 VGND VGND VPWR VPWR sky130_fd_sc_hd__decap_3
XFILLER_39_614 VGND VGND VPWR VPWR sky130_fd_sc_hd__fill_2
XFILLER_39_625 VGND VGND VPWR VPWR sky130_fd_sc_hd__fill_1
Xsingle_cycle_cpu VGND VGND VPWR VPWR single_cycle_cpu/HI instruction_out[19] sky130_fd_sc_hd__conb_1
XFILLER_38_124 VGND VGND VPWR VPWR sky130_fd_sc_hd__decap_3
XFILLER_39_647 VGND VGND VPWR VPWR sky130_fd_sc_hd__fill_1
XFILLER_66_433 VGND VGND VPWR VPWR sky130_fd_sc_hd__decap_3
XFILLER_38_168 VGND VGND VPWR VPWR sky130_fd_sc_hd__decap_3
XFILLER_53_105 VGND VGND VPWR VPWR sky130_fd_sc_hd__decap_3
XFILLER_54_606 VGND VGND VPWR VPWR sky130_fd_sc_hd__decap_3
XFILLER_66_477 VGND VGND VPWR VPWR sky130_fd_sc_hd__decap_3
XFILLER_93_274 VGND VGND VPWR VPWR sky130_fd_sc_hd__fill_2
XFILLER_19_393 VGND VGND VPWR VPWR sky130_fd_sc_hd__decap_3
XFILLER_53_116 VGND VGND VPWR VPWR sky130_fd_sc_hd__decap_3
X_6951_ _6978_/CLK _6951_/D VGND VGND VPWR VPWR _6951_/Q sky130_fd_sc_hd__dfxtp_2
XFILLER_81_458 VGND VGND VPWR VPWR sky130_fd_sc_hd__decap_3
X_6882_ _7384_/CLK _6882_/D VGND VGND VPWR VPWR _6882_/Q sky130_fd_sc_hd__dfxtp_2
XFILLER_34_363 VGND VGND VPWR VPWR sky130_fd_sc_hd__fill_1
XFILLER_14_29 VGND VGND VPWR VPWR sky130_fd_sc_hd__decap_3
XFILLER_22_536 VGND VGND VPWR VPWR sky130_fd_sc_hd__decap_3
XFILLER_61_193 VGND VGND VPWR VPWR sky130_fd_sc_hd__decap_3
X_5695_ _7353_/Q hold917/X _5706_/S VGND VGND VPWR VPWR _6697_/D sky130_fd_sc_hd__mux2_2
X_4646_ _4646_/A _4646_/B VGND VGND VPWR VPWR _4646_/Y sky130_fd_sc_hd__nand2_2
XFILLER_116_641 VGND VGND VPWR VPWR sky130_fd_sc_hd__decap_3
X_7365_ _7365_/CLK _7365_/D _6645_/Y VGND VGND VPWR VPWR _7365_/Q sky130_fd_sc_hd__dfrtp_2
Xhold710 _6823_/Q VGND VGND VPWR VPWR _6823_/D sky130_fd_sc_hd__dlygate4sd3_1
Xhold721 _6814_/Q VGND VGND VPWR VPWR _6814_/D sky130_fd_sc_hd__dlygate4sd3_1
X_4577_ _4577_/A _4583_/B VGND VGND VPWR VPWR _7292_/D sky130_fd_sc_hd__and2_2
XFILLER_89_503 VGND VGND VPWR VPWR sky130_fd_sc_hd__fill_1
XFILLER_89_514 VGND VGND VPWR VPWR sky130_fd_sc_hd__fill_2
Xhold732 _6748_/Q VGND VGND VPWR VPWR _6748_/D sky130_fd_sc_hd__dlygate4sd3_1
Xhold743 _6897_/Q VGND VGND VPWR VPWR _6897_/D sky130_fd_sc_hd__dlygate4sd3_1
Xhold754 _6967_/Q VGND VGND VPWR VPWR _6967_/D sky130_fd_sc_hd__dlygate4sd3_1
X_6316_ _6640_/A VGND VGND VPWR VPWR _6316_/Y sky130_fd_sc_hd__inv_2
XFILLER_103_302 VGND VGND VPWR VPWR sky130_fd_sc_hd__decap_3
X_7296_ _7396_/CLK _7296_/D _6576_/Y VGND VGND VPWR VPWR _7296_/Q sky130_fd_sc_hd__dfrtp_2
Xhold765 _6793_/Q VGND VGND VPWR VPWR _6793_/D sky130_fd_sc_hd__dlygate4sd3_1
Xhold776 _6903_/Q VGND VGND VPWR VPWR _6903_/D sky130_fd_sc_hd__dlygate4sd3_1
Xhold787 _6934_/Q VGND VGND VPWR VPWR _6934_/D sky130_fd_sc_hd__dlygate4sd3_1
X_3528_ _3528_/A _5118_/D VGND VGND VPWR VPWR _5659_/A sky130_fd_sc_hd__or2_2
XTAP_TAPCELL_ROW_73_1124 VGND VPWR sky130_fd_sc_hd__tapvpwrvgnd_1
XFILLER_103_335 VGND VGND VPWR VPWR sky130_fd_sc_hd__fill_1
XFILLER_103_346 VGND VGND VPWR VPWR sky130_fd_sc_hd__decap_3
XFILLER_89_558 VGND VGND VPWR VPWR sky130_fd_sc_hd__fill_2
Xhold798 _6848_/Q VGND VGND VPWR VPWR _6848_/D sky130_fd_sc_hd__dlygate4sd3_1
X_3459_ _7217_/Q _4340_/A2 _4246_/B1 _7121_/Q VGND VGND VPWR VPWR _3459_/X sky130_fd_sc_hd__a22o_2
XFILLER_103_379 VGND VGND VPWR VPWR sky130_fd_sc_hd__decap_3
XFILLER_29_102 VGND VGND VPWR VPWR sky130_fd_sc_hd__decap_3
XFILLER_57_411 VGND VGND VPWR VPWR sky130_fd_sc_hd__decap_3
XFILLER_29_113 VGND VGND VPWR VPWR sky130_fd_sc_hd__decap_3
XFILLER_69_293 VGND VGND VPWR VPWR sky130_fd_sc_hd__decap_3
X_5129_ _6982_/Q _5129_/B VGND VGND VPWR VPWR _5130_/C sky130_fd_sc_hd__nor2_2
XFILLER_29_146 VGND VGND VPWR VPWR sky130_fd_sc_hd__decap_3
XFILLER_55_25 VGND VGND VPWR VPWR sky130_fd_sc_hd__decap_3
XFILLER_57_455 VGND VGND VPWR VPWR sky130_fd_sc_hd__decap_3
XFILLER_57_477 VGND VGND VPWR VPWR sky130_fd_sc_hd__decap_3
XFILLER_38_680 VGND VGND VPWR VPWR sky130_fd_sc_hd__fill_1
XFILLER_72_436 VGND VGND VPWR VPWR sky130_fd_sc_hd__decap_3
XFILLER_84_285 VGND VGND VPWR VPWR sky130_fd_sc_hd__decap_3
XFILLER_111_31 VGND VGND VPWR VPWR sky130_fd_sc_hd__decap_3
XFILLER_25_352 VGND VGND VPWR VPWR sky130_fd_sc_hd__decap_3
XFILLER_37_190 VGND VGND VPWR VPWR sky130_fd_sc_hd__decap_3
XFILLER_72_469 VGND VGND VPWR VPWR sky130_fd_sc_hd__decap_3
XFILLER_25_385 VGND VGND VPWR VPWR sky130_fd_sc_hd__decap_3
XFILLER_40_300 VGND VGND VPWR VPWR sky130_fd_sc_hd__decap_3
XFILLER_52_171 VGND VGND VPWR VPWR sky130_fd_sc_hd__decap_3
XFILLER_80_480 VGND VGND VPWR VPWR sky130_fd_sc_hd__decap_3
XTAP_TAPCELL_ROW_84_1264 VGND VPWR sky130_fd_sc_hd__tapvpwrvgnd_1
XFILLER_111_75 VGND VGND VPWR VPWR sky130_fd_sc_hd__decap_3
XFILLER_40_333 VGND VGND VPWR VPWR sky130_fd_sc_hd__decap_3
XTAP_TAPCELL_ROW_23_531 VGND VPWR sky130_fd_sc_hd__tapvpwrvgnd_1
XFILLER_40_377 VGND VGND VPWR VPWR sky130_fd_sc_hd__decap_3
XFILLER_71_57 VGND VGND VPWR VPWR sky130_fd_sc_hd__decap_3
XTAP_TAPCELL_ROW_51_862 VGND VPWR sky130_fd_sc_hd__tapvpwrvgnd_1
XFILLER_21_591 VGND VGND VPWR VPWR sky130_fd_sc_hd__decap_3
XFILLER_40_399 VGND VGND VPWR VPWR sky130_fd_sc_hd__decap_3
XFILLER_20_50 VGND VGND VPWR VPWR sky130_fd_sc_hd__decap_3
XFILLER_4_267 VGND VGND VPWR VPWR sky130_fd_sc_hd__decap_3
XTAP_TAPCELL_ROW_95_1393 VGND VPWR sky130_fd_sc_hd__tapvpwrvgnd_1
XFILLER_106_195 VGND VGND VPWR VPWR sky130_fd_sc_hd__fill_1
XFILLER_96_43 VGND VGND VPWR VPWR sky130_fd_sc_hd__fill_2
XFILLER_48_400 VGND VGND VPWR VPWR sky130_fd_sc_hd__decap_3
XFILLER_67_219 VGND VGND VPWR VPWR sky130_fd_sc_hd__decap_3
XFILLER_95_517 VGND VGND VPWR VPWR sky130_fd_sc_hd__decap_3
XFILLER_96_65 VGND VGND VPWR VPWR sky130_fd_sc_hd__decap_3
XFILLER_102_390 VGND VGND VPWR VPWR sky130_fd_sc_hd__decap_3
XFILLER_48_433 VGND VGND VPWR VPWR sky130_fd_sc_hd__decap_3
XFILLER_29_81 VGND VGND VPWR VPWR sky130_fd_sc_hd__decap_3
XFILLER_48_477 VGND VGND VPWR VPWR sky130_fd_sc_hd__decap_3
XFILLER_75_252 VGND VGND VPWR VPWR sky130_fd_sc_hd__decap_3
XTAP_TAPCELL_ROW_59_962 VGND VPWR sky130_fd_sc_hd__tapvpwrvgnd_1
XFILLER_35_116 VGND VGND VPWR VPWR sky130_fd_sc_hd__decap_3
XFILLER_63_414 VGND VGND VPWR VPWR sky130_fd_sc_hd__decap_3
XFILLER_63_447 VGND VGND VPWR VPWR sky130_fd_sc_hd__fill_1
XFILLER_90_222 VGND VGND VPWR VPWR sky130_fd_sc_hd__decap_3
Xplace403 _4507_/S VGND VGND VPWR VPWR _4510_/S sky130_fd_sc_hd__buf_2
XFILLER_51_609 VGND VGND VPWR VPWR sky130_fd_sc_hd__decap_3
Xplace414 _4437_/B1 VGND VGND VPWR VPWR _4399_/A2 sky130_fd_sc_hd__buf_2
Xplace425 _3947_/S VGND VGND VPWR VPWR _3943_/S sky130_fd_sc_hd__buf_2
Xplace436 _3366_/X VGND VGND VPWR VPWR _4430_/B1 sky130_fd_sc_hd__buf_2
Xplace447 _4960_/A VGND VGND VPWR VPWR _5587_/B sky130_fd_sc_hd__buf_2
XPHY_EDGE_ROW_82_Left_199 VGND VGND VPWR VPWR sky130_fd_sc_hd__decap_3
XFILLER_16_374 VGND VGND VPWR VPWR sky130_fd_sc_hd__fill_1
XFILLER_43_160 VGND VGND VPWR VPWR sky130_fd_sc_hd__decap_3
XFILLER_45_91 VGND VGND VPWR VPWR sky130_fd_sc_hd__decap_3
XFILLER_90_277 VGND VGND VPWR VPWR sky130_fd_sc_hd__decap_3
Xplace458 _6982_/Q VGND VGND VPWR VPWR _3386_/A sky130_fd_sc_hd__buf_2
XFILLER_16_396 VGND VGND VPWR VPWR sky130_fd_sc_hd__decap_3
XFILLER_43_193 VGND VGND VPWR VPWR sky130_fd_sc_hd__decap_3
XFILLER_91_6 VGND VGND VPWR VPWR sky130_fd_sc_hd__decap_3
XFILLER_31_388 VGND VGND VPWR VPWR sky130_fd_sc_hd__fill_1
XANTENNA_1 _5117_/B VGND VGND VPWR VPWR sky130_fd_sc_hd__diode_2
X_4431_ _7271_/Q _4437_/A2 _4428_/X _4430_/X VGND VGND VPWR VPWR _4431_/X sky130_fd_sc_hd__a211o_2
X_7150_ _7340_/CLK _7150_/D _6430_/Y VGND VGND VPWR VPWR _7150_/Q sky130_fd_sc_hd__dfrtp_2
X_4362_ _4362_/A _4362_/B _4362_/C VGND VGND VPWR VPWR _4362_/X sky130_fd_sc_hd__and3_2
XFILLER_86_506 VGND VGND VPWR VPWR sky130_fd_sc_hd__decap_3
X_7081_ _7330_/CLK _7081_/D _6361_/Y VGND VGND VPWR VPWR _7081_/Q sky130_fd_sc_hd__dfrtp_2
X_4293_ _4291_/A _4612_/B VGND VGND VPWR VPWR _4293_/X sky130_fd_sc_hd__and2b_2
X_3313_ _6983_/Q _3353_/A _3327_/A _3386_/A VGND VGND VPWR VPWR _4467_/B sky130_fd_sc_hd__nand4b_4
XFILLER_112_154 VGND VGND VPWR VPWR sky130_fd_sc_hd__fill_2
XFILLER_39_411 VGND VGND VPWR VPWR sky130_fd_sc_hd__decap_3
XFILLER_86_517 VGND VGND VPWR VPWR sky130_fd_sc_hd__decap_3
XFILLER_86_539 VGND VGND VPWR VPWR sky130_fd_sc_hd__decap_3
XFILLER_98_377 VGND VGND VPWR VPWR sky130_fd_sc_hd__decap_3
XFILLER_79_580 VGND VGND VPWR VPWR sky130_fd_sc_hd__decap_3
XFILLER_27_617 VGND VGND VPWR VPWR sky130_fd_sc_hd__decap_3
XFILLER_54_403 VGND VGND VPWR VPWR sky130_fd_sc_hd__decap_3
XFILLER_66_230 VGND VGND VPWR VPWR sky130_fd_sc_hd__decap_3
XFILLER_26_127 VGND VGND VPWR VPWR sky130_fd_sc_hd__decap_3
XFILLER_39_499 VGND VGND VPWR VPWR sky130_fd_sc_hd__fill_2
XFILLER_81_211 VGND VGND VPWR VPWR sky130_fd_sc_hd__decap_3
X_6934_ _7404_/CLK _6934_/D VGND VGND VPWR VPWR _6934_/Q sky130_fd_sc_hd__dfxtp_2
XTAP_TAPCELL_ROW_1_259 VGND VPWR sky130_fd_sc_hd__tapvpwrvgnd_1
XFILLER_25_39 VGND VGND VPWR VPWR sky130_fd_sc_hd__decap_3
XFILLER_41_119 VGND VGND VPWR VPWR sky130_fd_sc_hd__decap_3
XFILLER_22_333 VGND VGND VPWR VPWR sky130_fd_sc_hd__decap_3
XFILLER_34_182 VGND VGND VPWR VPWR sky130_fd_sc_hd__decap_3
XFILLER_62_480 VGND VGND VPWR VPWR sky130_fd_sc_hd__decap_3
X_6865_ _7383_/CLK _6865_/D VGND VGND VPWR VPWR _6865_/Q sky130_fd_sc_hd__dfxtp_2
XFILLER_22_377 VGND VGND VPWR VPWR sky130_fd_sc_hd__decap_3
X_6796_ _7390_/CLK _6796_/D VGND VGND VPWR VPWR _6796_/Q sky130_fd_sc_hd__dfxtp_2
XFILLER_108_416 VGND VGND VPWR VPWR sky130_fd_sc_hd__decap_3
XFILLER_108_427 VGND VGND VPWR VPWR sky130_fd_sc_hd__decap_3
X_5678_ _7345_/Q hold941/X _5706_/S VGND VGND VPWR VPWR _5678_/X sky130_fd_sc_hd__mux2_2
X_4629_ _4629_/A _4629_/B VGND VGND VPWR VPWR _4629_/Y sky130_fd_sc_hd__nor2_2
XFILLER_104_600 VGND VGND VPWR VPWR sky130_fd_sc_hd__decap_3
XFILLER_104_622 VGND VGND VPWR VPWR sky130_fd_sc_hd__decap_3
X_7348_ _7351_/CLK _7348_/D _6628_/Y VGND VGND VPWR VPWR _7348_/Q sky130_fd_sc_hd__dfrtp_2
XFILLER_103_132 VGND VGND VPWR VPWR sky130_fd_sc_hd__decap_3
XFILLER_104_666 VGND VGND VPWR VPWR sky130_fd_sc_hd__fill_2
XFILLER_116_493 VGND VGND VPWR VPWR sky130_fd_sc_hd__decap_3
X_7279_ clkload7/A _7279_/D _6559_/Y VGND VGND VPWR VPWR _7279_/Q sky130_fd_sc_hd__dfrtp_2
Xhold595 _6796_/Q VGND VGND VPWR VPWR _6796_/D sky130_fd_sc_hd__dlygate4sd3_1
XTAP_TAPCELL_ROW_9_359 VGND VPWR sky130_fd_sc_hd__tapvpwrvgnd_1
XFILLER_106_42 VGND VGND VPWR VPWR sky130_fd_sc_hd__fill_2
XFILLER_77_517 VGND VGND VPWR VPWR sky130_fd_sc_hd__decap_3
XFILLER_89_399 VGND VGND VPWR VPWR sky130_fd_sc_hd__decap_3
XFILLER_103_187 VGND VGND VPWR VPWR sky130_fd_sc_hd__decap_3
XFILLER_66_35 VGND VGND VPWR VPWR sky130_fd_sc_hd__decap_3
XFILLER_57_252 VGND VGND VPWR VPWR sky130_fd_sc_hd__decap_3
XFILLER_66_68 VGND VGND VPWR VPWR sky130_fd_sc_hd__decap_3
XFILLER_17_116 VGND VGND VPWR VPWR sky130_fd_sc_hd__decap_3
XFILLER_45_414 VGND VGND VPWR VPWR sky130_fd_sc_hd__decap_3
XFILLER_57_296 VGND VGND VPWR VPWR sky130_fd_sc_hd__decap_3
XFILLER_72_200 VGND VGND VPWR VPWR sky130_fd_sc_hd__decap_3
XFILLER_72_222 VGND VGND VPWR VPWR sky130_fd_sc_hd__decap_3
XTAP_TAPCELL_ROW_56_921 VGND VPWR sky130_fd_sc_hd__tapvpwrvgnd_1
XFILLER_45_458 VGND VGND VPWR VPWR sky130_fd_sc_hd__decap_3
XFILLER_82_12 VGND VGND VPWR VPWR sky130_fd_sc_hd__fill_2
XFILLER_13_300 VGND VGND VPWR VPWR sky130_fd_sc_hd__decap_3
XFILLER_60_406 VGND VGND VPWR VPWR sky130_fd_sc_hd__decap_3
XFILLER_72_277 VGND VGND VPWR VPWR sky130_fd_sc_hd__fill_1
XFILLER_25_193 VGND VGND VPWR VPWR sky130_fd_sc_hd__decap_3
XFILLER_60_439 VGND VGND VPWR VPWR sky130_fd_sc_hd__decap_3
XFILLER_13_366 VGND VGND VPWR VPWR sky130_fd_sc_hd__decap_3
XFILLER_15_83 VGND VGND VPWR VPWR sky130_fd_sc_hd__decap_3
XFILLER_40_130 VGND VGND VPWR VPWR sky130_fd_sc_hd__decap_3
XFILLER_40_141 VGND VGND VPWR VPWR sky130_fd_sc_hd__decap_3
XFILLER_13_399 VGND VGND VPWR VPWR sky130_fd_sc_hd__fill_1
XFILLER_40_174 VGND VGND VPWR VPWR sky130_fd_sc_hd__decap_3
XFILLER_9_337 VGND VGND VPWR VPWR sky130_fd_sc_hd__decap_3
XTAP_TAPCELL_ROW_97_1411 VGND VPWR sky130_fd_sc_hd__tapvpwrvgnd_1
XFILLER_56_9 VGND VGND VPWR VPWR sky130_fd_sc_hd__decap_3
XFILLER_99_108 VGND VGND VPWR VPWR sky130_fd_sc_hd__decap_3
XFILLER_110_625 VGND VGND VPWR VPWR sky130_fd_sc_hd__decap_3
XFILLER_68_506 VGND VGND VPWR VPWR sky130_fd_sc_hd__fill_2
XFILLER_68_517 VGND VGND VPWR VPWR sky130_fd_sc_hd__decap_3
XFILLER_68_539 VGND VGND VPWR VPWR sky130_fd_sc_hd__decap_3
XFILLER_48_241 VGND VGND VPWR VPWR sky130_fd_sc_hd__decap_3
XFILLER_76_561 VGND VGND VPWR VPWR sky130_fd_sc_hd__decap_3
XFILLER_63_200 VGND VGND VPWR VPWR sky130_fd_sc_hd__decap_3
XFILLER_63_211 VGND VGND VPWR VPWR sky130_fd_sc_hd__decap_3
XFILLER_91_520 VGND VGND VPWR VPWR sky130_fd_sc_hd__fill_1
XPHY_EDGE_ROW_90_Left_207 VGND VGND VPWR VPWR sky130_fd_sc_hd__decap_3
XFILLER_17_650 VGND VGND VPWR VPWR sky130_fd_sc_hd__decap_3
XFILLER_36_458 VGND VGND VPWR VPWR sky130_fd_sc_hd__decap_3
XFILLER_63_222 VGND VGND VPWR VPWR sky130_fd_sc_hd__fill_2
XFILLER_91_542 VGND VGND VPWR VPWR sky130_fd_sc_hd__decap_3
XFILLER_91_564 VGND VGND VPWR VPWR sky130_fd_sc_hd__decap_3
XFILLER_23_108 VGND VGND VPWR VPWR sky130_fd_sc_hd__decap_3
XFILLER_23_119 VGND VGND VPWR VPWR sky130_fd_sc_hd__decap_3
XFILLER_16_171 VGND VGND VPWR VPWR sky130_fd_sc_hd__decap_3
XFILLER_44_480 VGND VGND VPWR VPWR sky130_fd_sc_hd__decap_3
XFILLER_63_299 VGND VGND VPWR VPWR sky130_fd_sc_hd__decap_3
Xplace288 _3906_/B1 VGND VGND VPWR VPWR _3925_/A2 sky130_fd_sc_hd__buf_2
Xplace277 _3665_/X VGND VGND VPWR VPWR _3852_/B1 sky130_fd_sc_hd__buf_2
Xplace266 _3682_/A VGND VGND VPWR VPWR _3629_/A sky130_fd_sc_hd__buf_2
X_3931_ _7374_/Q _4474_/A0 _3947_/S VGND VGND VPWR VPWR _7374_/D sky130_fd_sc_hd__mux2_2
XTAP_TAPCELL_ROW_34_659 VGND VPWR sky130_fd_sc_hd__tapvpwrvgnd_1
Xplace299 _3882_/A2 VGND VGND VPWR VPWR _3825_/B1 sky130_fd_sc_hd__buf_2
X_6650_ _6683_/A VGND VGND VPWR VPWR _6650_/Y sky130_fd_sc_hd__inv_2
X_3862_ _6923_/Q _3926_/A2 _3922_/A2 _6787_/Q VGND VGND VPWR VPWR _3862_/X sky130_fd_sc_hd__a22o_2
XFILLER_31_185 VGND VGND VPWR VPWR sky130_fd_sc_hd__decap_3
X_6581_ _6642_/A VGND VGND VPWR VPWR _6581_/Y sky130_fd_sc_hd__inv_2
X_3793_ _6756_/Q _3889_/B1 _3881_/B1 _6768_/Q VGND VGND VPWR VPWR _3793_/X sky130_fd_sc_hd__a22o_2
X_7202_ _7361_/CLK _7202_/D _6482_/Y VGND VGND VPWR VPWR _7202_/Q sky130_fd_sc_hd__dfrtp_2
X_5394_ _5394_/A0 _4964_/X _5398_/S VGND VGND VPWR VPWR _7136_/D sky130_fd_sc_hd__mux2_2
X_4414_ _7240_/Q _4414_/A2 _4414_/B1 _7208_/Q VGND VGND VPWR VPWR _4414_/X sky130_fd_sc_hd__a22o_2
XFILLER_99_620 VGND VGND VPWR VPWR sky130_fd_sc_hd__decap_3
XFILLER_113_441 VGND VGND VPWR VPWR sky130_fd_sc_hd__decap_3
X_7133_ clkload6/A _7133_/D _6413_/Y VGND VGND VPWR VPWR _7133_/Q sky130_fd_sc_hd__dfrtp_2
X_4345_ _4343_/X _4345_/B VGND VGND VPWR VPWR _5101_/B sky130_fd_sc_hd__nand2b_2
XFILLER_113_452 VGND VGND VPWR VPWR sky130_fd_sc_hd__decap_3
XFILLER_59_517 VGND VGND VPWR VPWR sky130_fd_sc_hd__decap_3
XTAP_TAPCELL_ROW_6_329 VGND VPWR sky130_fd_sc_hd__tapvpwrvgnd_1
XTAP_TAPCELL_ROW_6_318 VGND VPWR sky130_fd_sc_hd__tapvpwrvgnd_1
XFILLER_98_141 VGND VGND VPWR VPWR sky130_fd_sc_hd__decap_3
XFILLER_59_539 VGND VGND VPWR VPWR sky130_fd_sc_hd__decap_3
XFILLER_86_336 VGND VGND VPWR VPWR sky130_fd_sc_hd__decap_3
X_7064_ clkload9/A _7064_/D _6344_/Y VGND VGND VPWR VPWR _7064_/Q sky130_fd_sc_hd__dfrtp_2
XFILLER_39_241 VGND VGND VPWR VPWR sky130_fd_sc_hd__decap_3
XFILLER_67_550 VGND VGND VPWR VPWR sky130_fd_sc_hd__decap_3
XFILLER_67_561 VGND VGND VPWR VPWR sky130_fd_sc_hd__fill_1
XFILLER_54_200 VGND VGND VPWR VPWR sky130_fd_sc_hd__decap_3
XFILLER_67_594 VGND VGND VPWR VPWR sky130_fd_sc_hd__decap_3
XFILLER_27_436 VGND VGND VPWR VPWR sky130_fd_sc_hd__decap_3
XFILLER_54_233 VGND VGND VPWR VPWR sky130_fd_sc_hd__decap_3
XFILLER_82_542 VGND VGND VPWR VPWR sky130_fd_sc_hd__decap_3
XFILLER_82_586 VGND VGND VPWR VPWR sky130_fd_sc_hd__fill_2
XTAP_TAPCELL_ROW_68_1067 VGND VPWR sky130_fd_sc_hd__tapvpwrvgnd_1
XFILLER_35_480 VGND VGND VPWR VPWR sky130_fd_sc_hd__decap_3
XFILLER_35_491 VGND VGND VPWR VPWR sky130_fd_sc_hd__decap_3
XFILLER_54_299 VGND VGND VPWR VPWR sky130_fd_sc_hd__decap_3
X_6917_ _7384_/CLK _6917_/D VGND VGND VPWR VPWR _6917_/Q sky130_fd_sc_hd__dfxtp_2
XTAP_TAPCELL_ROW_81_1223 VGND VPWR sky130_fd_sc_hd__tapvpwrvgnd_1
XFILLER_22_141 VGND VGND VPWR VPWR sky130_fd_sc_hd__decap_3
X_6848_ _6909_/CLK _6848_/D VGND VGND VPWR VPWR _6848_/Q sky130_fd_sc_hd__dfxtp_2
XFILLER_50_472 VGND VGND VPWR VPWR sky130_fd_sc_hd__fill_1
XFILLER_10_336 VGND VGND VPWR VPWR sky130_fd_sc_hd__decap_3
X_6779_ _6936_/CLK _6779_/D VGND VGND VPWR VPWR _6779_/Q sky130_fd_sc_hd__dfxtp_2
XFILLER_6_318 VGND VGND VPWR VPWR sky130_fd_sc_hd__decap_3
XFILLER_2_513 VGND VGND VPWR VPWR sky130_fd_sc_hd__decap_3
XTAP_TAPCELL_ROW_79_1196 VGND VPWR sky130_fd_sc_hd__tapvpwrvgnd_1
XFILLER_104_430 VGND VGND VPWR VPWR sky130_fd_sc_hd__decap_3
XFILLER_77_12 VGND VGND VPWR VPWR sky130_fd_sc_hd__decap_3
XTAP_TAPCELL_ROW_92_1352 VGND VPWR sky130_fd_sc_hd__tapvpwrvgnd_1
XFILLER_89_163 VGND VGND VPWR VPWR sky130_fd_sc_hd__fill_1
XFILLER_77_358 VGND VGND VPWR VPWR sky130_fd_sc_hd__decap_3
XFILLER_73_520 VGND VGND VPWR VPWR sky130_fd_sc_hd__decap_3
XFILLER_85_380 VGND VGND VPWR VPWR sky130_fd_sc_hd__decap_3
XFILLER_18_447 VGND VGND VPWR VPWR sky130_fd_sc_hd__decap_3
XFILLER_45_222 VGND VGND VPWR VPWR sky130_fd_sc_hd__fill_2
XFILLER_93_55 VGND VGND VPWR VPWR sky130_fd_sc_hd__fill_1
XFILLER_93_66 VGND VGND VPWR VPWR sky130_fd_sc_hd__fill_2
Xhold1070 _7239_/Q VGND VGND VPWR VPWR _5177_/A sky130_fd_sc_hd__dlygate4sd3_1
Xhold1081 _7289_/Q VGND VGND VPWR VPWR _4583_/A sky130_fd_sc_hd__dlygate4sd3_1
Xhold1092 _7236_/Q VGND VGND VPWR VPWR _5184_/A sky130_fd_sc_hd__dlygate4sd3_1
XFILLER_73_575 VGND VGND VPWR VPWR sky130_fd_sc_hd__decap_3
XFILLER_93_88 VGND VGND VPWR VPWR sky130_fd_sc_hd__decap_3
XFILLER_26_491 VGND VGND VPWR VPWR sky130_fd_sc_hd__decap_3
XFILLER_26_82 VGND VGND VPWR VPWR sky130_fd_sc_hd__fill_2
XFILLER_45_299 VGND VGND VPWR VPWR sky130_fd_sc_hd__decap_3
XFILLER_60_214 VGND VGND VPWR VPWR sky130_fd_sc_hd__decap_3
XFILLER_60_247 VGND VGND VPWR VPWR sky130_fd_sc_hd__decap_3
XFILLER_13_163 VGND VGND VPWR VPWR sky130_fd_sc_hd__decap_3
XFILLER_41_472 VGND VGND VPWR VPWR sky130_fd_sc_hd__decap_3
XTAP_TAPCELL_ROW_31_629 VGND VPWR sky130_fd_sc_hd__tapvpwrvgnd_1
XTAP_TAPCELL_ROW_31_618 VGND VPWR sky130_fd_sc_hd__tapvpwrvgnd_1
XFILLER_9_134 VGND VGND VPWR VPWR sky130_fd_sc_hd__decap_3
XFILLER_13_196 VGND VGND VPWR VPWR sky130_fd_sc_hd__decap_3
XFILLER_9_167 VGND VGND VPWR VPWR sky130_fd_sc_hd__fill_1
XFILLER_42_81 VGND VGND VPWR VPWR sky130_fd_sc_hd__decap_3
XFILLER_9_178 VGND VGND VPWR VPWR sky130_fd_sc_hd__decap_3
XFILLER_5_340 VGND VGND VPWR VPWR sky130_fd_sc_hd__decap_3
XTAP_TAPCELL_ROW_11_386 VGND VPWR sky130_fd_sc_hd__tapvpwrvgnd_1
XFILLER_114_205 VGND VGND VPWR VPWR sky130_fd_sc_hd__fill_1
XFILLER_54_6 VGND VGND VPWR VPWR sky130_fd_sc_hd__decap_3
XFILLER_5_373 VGND VGND VPWR VPWR sky130_fd_sc_hd__decap_3
XFILLER_68_303 VGND VGND VPWR VPWR sky130_fd_sc_hd__decap_3
X_4130_ _7235_/Q _4349_/B1 _3366_/X _7171_/Q _4129_/X VGND VGND VPWR VPWR _4130_/X
+ sky130_fd_sc_hd__a221o_2
XFILLER_110_433 VGND VGND VPWR VPWR sky130_fd_sc_hd__decap_3
XFILLER_3_64 VGND VGND VPWR VPWR sky130_fd_sc_hd__decap_3
XFILLER_68_347 VGND VGND VPWR VPWR sky130_fd_sc_hd__decap_3
XFILLER_96_634 VGND VGND VPWR VPWR sky130_fd_sc_hd__decap_3
XFILLER_110_466 VGND VGND VPWR VPWR sky130_fd_sc_hd__decap_3
XFILLER_83_306 VGND VGND VPWR VPWR sky130_fd_sc_hd__decap_3
XFILLER_95_133 VGND VGND VPWR VPWR sky130_fd_sc_hd__decap_3
XFILLER_96_678 VGND VGND VPWR VPWR sky130_fd_sc_hd__decap_3
X_4061_ _7244_/Q _4433_/B _4436_/B1 _7180_/Q VGND VGND VPWR VPWR _4061_/X sky130_fd_sc_hd__a22o_2
XFILLER_95_199 VGND VGND VPWR VPWR sky130_fd_sc_hd__decap_3
XTAP_TAPCELL_ROW_39_718 VGND VPWR sky130_fd_sc_hd__tapvpwrvgnd_1
XFILLER_36_233 VGND VGND VPWR VPWR sky130_fd_sc_hd__decap_3
XFILLER_64_531 VGND VGND VPWR VPWR sky130_fd_sc_hd__fill_1
XFILLER_64_542 VGND VGND VPWR VPWR sky130_fd_sc_hd__decap_3
XFILLER_76_380 VGND VGND VPWR VPWR sky130_fd_sc_hd__decap_3
XFILLER_24_406 VGND VGND VPWR VPWR sky130_fd_sc_hd__decap_3
XFILLER_51_203 VGND VGND VPWR VPWR sky130_fd_sc_hd__decap_3
XFILLER_91_361 VGND VGND VPWR VPWR sky130_fd_sc_hd__decap_3
XFILLER_51_225 VGND VGND VPWR VPWR sky130_fd_sc_hd__decap_3
X_4963_ _4963_/A _4963_/B VGND VGND VPWR VPWR _6994_/D sky130_fd_sc_hd__nor2_2
XTAP_TAPCELL_ROW_19_475 VGND VPWR sky130_fd_sc_hd__tapvpwrvgnd_1
XFILLER_51_247 VGND VGND VPWR VPWR sky130_fd_sc_hd__decap_3
XFILLER_51_269 VGND VGND VPWR VPWR sky130_fd_sc_hd__fill_1
X_6702_ _7390_/CLK _6702_/D VGND VGND VPWR VPWR _6702_/Q sky130_fd_sc_hd__dfxtp_2
X_3914_ _3682_/A _3911_/X _3913_/X _3714_/X VGND VGND VPWR VPWR _3914_/X sky130_fd_sc_hd__a22o_2
X_6633_ _6640_/A VGND VGND VPWR VPWR _6633_/Y sky130_fd_sc_hd__inv_2
X_4894_ _4908_/A _4908_/B VGND VGND VPWR VPWR _4909_/B sky130_fd_sc_hd__and2_2
XFILLER_22_18 VGND VGND VPWR VPWR sky130_fd_sc_hd__decap_3
XFILLER_22_29 VGND VGND VPWR VPWR sky130_fd_sc_hd__decap_3
X_3845_ _3845_/A _3845_/B VGND VGND VPWR VPWR _3845_/X sky130_fd_sc_hd__or2_2
X_6564_ _6599_/A VGND VGND VPWR VPWR _6564_/Y sky130_fd_sc_hd__inv_2
X_3776_ _6727_/Q _3852_/A2 _3853_/A2 _6977_/Q VGND VGND VPWR VPWR _3776_/X sky130_fd_sc_hd__a22o_2
X_6495_ _6608_/A VGND VGND VPWR VPWR _6495_/Y sky130_fd_sc_hd__inv_2
XFILLER_9_690 VGND VGND VPWR VPWR sky130_fd_sc_hd__fill_2
XFILLER_105_205 VGND VGND VPWR VPWR sky130_fd_sc_hd__decap_3
XTAP_TAPCELL_ROW_115_1628 VGND VPWR sky130_fd_sc_hd__tapvpwrvgnd_1
Xoutput486 _5653_/Y VGND VGND VPWR VPWR alu_result_out[29] sky130_fd_sc_hd__clkdlybuf4s25_1
Xoutput475 place74/X VGND VGND VPWR VPWR alu_result_out[19] sky130_fd_sc_hd__clkdlybuf4s25_1
X_5377_ _5377_/A0 _4822_/X _5383_/S VGND VGND VPWR VPWR _7144_/D sky130_fd_sc_hd__mux2_2
XFILLER_99_461 VGND VGND VPWR VPWR sky130_fd_sc_hd__decap_3
XFILLER_101_433 VGND VGND VPWR VPWR sky130_fd_sc_hd__decap_3
XFILLER_113_271 VGND VGND VPWR VPWR sky130_fd_sc_hd__decap_3
XFILLER_59_314 VGND VGND VPWR VPWR sky130_fd_sc_hd__decap_3
XFILLER_86_100 VGND VGND VPWR VPWR sky130_fd_sc_hd__decap_3
X_7116_ _7340_/CLK _7116_/D _6396_/Y VGND VGND VPWR VPWR _7116_/Q sky130_fd_sc_hd__dfrtp_2
Xoutput497 _3378_/A VGND VGND VPWR VPWR instruction_out[10] sky130_fd_sc_hd__clkdlybuf4s25_1
X_4328_ _4362_/A _4362_/B _4362_/C VGND VGND VPWR VPWR _5057_/B sky130_fd_sc_hd__a21boi_2
XFILLER_99_494 VGND VGND VPWR VPWR sky130_fd_sc_hd__decap_3
XFILLER_101_455 VGND VGND VPWR VPWR sky130_fd_sc_hd__decap_3
XFILLER_113_293 VGND VGND VPWR VPWR sky130_fd_sc_hd__decap_3
XFILLER_47_15 VGND VGND VPWR VPWR sky130_fd_sc_hd__decap_3
XFILLER_86_133 VGND VGND VPWR VPWR sky130_fd_sc_hd__decap_3
XFILLER_86_144 VGND VGND VPWR VPWR sky130_fd_sc_hd__decap_3
XFILLER_87_689 VGND VGND VPWR VPWR sky130_fd_sc_hd__decap_3
X_7047_ _7393_/CLK _7047_/D _6327_/Y VGND VGND VPWR VPWR _7047_/Q sky130_fd_sc_hd__dfrtp_2
XFILLER_47_48 VGND VGND VPWR VPWR sky130_fd_sc_hd__decap_3
XFILLER_86_177 VGND VGND VPWR VPWR sky130_fd_sc_hd__decap_3
XFILLER_103_21 VGND VGND VPWR VPWR sky130_fd_sc_hd__decap_3
XFILLER_103_43 VGND VGND VPWR VPWR sky130_fd_sc_hd__decap_3
XFILLER_15_417 VGND VGND VPWR VPWR sky130_fd_sc_hd__decap_3
XFILLER_42_203 VGND VGND VPWR VPWR sky130_fd_sc_hd__decap_3
XFILLER_82_361 VGND VGND VPWR VPWR sky130_fd_sc_hd__decap_3
XFILLER_27_299 VGND VGND VPWR VPWR sky130_fd_sc_hd__decap_3
XFILLER_63_25 VGND VGND VPWR VPWR sky130_fd_sc_hd__fill_2
XFILLER_70_523 VGND VGND VPWR VPWR sky130_fd_sc_hd__decap_3
XFILLER_70_545 VGND VGND VPWR VPWR sky130_fd_sc_hd__decap_3
XFILLER_82_394 VGND VGND VPWR VPWR sky130_fd_sc_hd__decap_3
XFILLER_30_409 VGND VGND VPWR VPWR sky130_fd_sc_hd__decap_3
XFILLER_23_483 VGND VGND VPWR VPWR sky130_fd_sc_hd__decap_3
XFILLER_70_589 VGND VGND VPWR VPWR sky130_fd_sc_hd__decap_3
XFILLER_50_291 VGND VGND VPWR VPWR sky130_fd_sc_hd__decap_3
XFILLER_109_511 VGND VGND VPWR VPWR sky130_fd_sc_hd__decap_3
XFILLER_10_144 VGND VGND VPWR VPWR sky130_fd_sc_hd__decap_3
XFILLER_10_166 VGND VGND VPWR VPWR sky130_fd_sc_hd__decap_3
XFILLER_6_115 VGND VGND VPWR VPWR sky130_fd_sc_hd__fill_1
XFILLER_109_555 VGND VGND VPWR VPWR sky130_fd_sc_hd__decap_3
XFILLER_12_62 VGND VGND VPWR VPWR sky130_fd_sc_hd__decap_3
XFILLER_6_137 VGND VGND VPWR VPWR sky130_fd_sc_hd__decap_3
XFILLER_109_588 VGND VGND VPWR VPWR sky130_fd_sc_hd__decap_3
XFILLER_2_365 VGND VGND VPWR VPWR sky130_fd_sc_hd__decap_3
XFILLER_78_601 VGND VGND VPWR VPWR sky130_fd_sc_hd__decap_3
XFILLER_88_88 VGND VGND VPWR VPWR sky130_fd_sc_hd__decap_3
XFILLER_2_398 VGND VGND VPWR VPWR sky130_fd_sc_hd__fill_1
XFILLER_78_634 VGND VGND VPWR VPWR sky130_fd_sc_hd__decap_3
XFILLER_78_645 VGND VGND VPWR VPWR sky130_fd_sc_hd__decap_3
XFILLER_104_293 VGND VGND VPWR VPWR sky130_fd_sc_hd__decap_3
XFILLER_77_144 VGND VGND VPWR VPWR sky130_fd_sc_hd__decap_3
XFILLER_18_200 VGND VGND VPWR VPWR sky130_fd_sc_hd__decap_3
XFILLER_65_328 VGND VGND VPWR VPWR sky130_fd_sc_hd__decap_3
XFILLER_92_103 VGND VGND VPWR VPWR sky130_fd_sc_hd__decap_3
XFILLER_93_626 VGND VGND VPWR VPWR sky130_fd_sc_hd__decap_3
XFILLER_92_147 VGND VGND VPWR VPWR sky130_fd_sc_hd__decap_3
XFILLER_18_244 VGND VGND VPWR VPWR sky130_fd_sc_hd__decap_3
XFILLER_18_277 VGND VGND VPWR VPWR sky130_fd_sc_hd__decap_3
XFILLER_73_361 VGND VGND VPWR VPWR sky130_fd_sc_hd__decap_3
XFILLER_80_309 VGND VGND VPWR VPWR sky130_fd_sc_hd__decap_3
XFILLER_33_225 VGND VGND VPWR VPWR sky130_fd_sc_hd__decap_3
XFILLER_73_383 VGND VGND VPWR VPWR sky130_fd_sc_hd__decap_3
XFILLER_33_269 VGND VGND VPWR VPWR sky130_fd_sc_hd__decap_3
XFILLER_61_567 VGND VGND VPWR VPWR sky130_fd_sc_hd__decap_3
XTAP_TAPCELL_ROW_16_445 VGND VPWR sky130_fd_sc_hd__tapvpwrvgnd_1
XTAP_TAPCELL_ROW_44_776 VGND VPWR sky130_fd_sc_hd__tapvpwrvgnd_1
X_3630_ _3630_/A _3630_/B VGND VGND VPWR VPWR _3636_/B sky130_fd_sc_hd__and2_2
X_3561_ _3561_/A _3561_/B _5668_/A VGND VGND VPWR VPWR _3561_/X sky130_fd_sc_hd__or3_2
X_5300_ _5300_/A0 _4752_/X _5325_/S VGND VGND VPWR VPWR _7180_/D sky130_fd_sc_hd__mux2_2
XFILLER_115_536 VGND VGND VPWR VPWR sky130_fd_sc_hd__decap_3
XFILLER_5_181 VGND VGND VPWR VPWR sky130_fd_sc_hd__decap_3
X_6280_ _6462_/A VGND VGND VPWR VPWR _6280_/Y sky130_fd_sc_hd__inv_2
X_3492_ _7055_/Q _3577_/B _3487_/X _3491_/X VGND VGND VPWR VPWR _4460_/B sky130_fd_sc_hd__o22a_2
XFILLER_102_208 VGND VGND VPWR VPWR sky130_fd_sc_hd__decap_3
XFILLER_115_569 VGND VGND VPWR VPWR sky130_fd_sc_hd__decap_3
XFILLER_69_612 VGND VGND VPWR VPWR sky130_fd_sc_hd__decap_3
XFILLER_68_122 VGND VGND VPWR VPWR sky130_fd_sc_hd__decap_3
XFILLER_69_634 VGND VGND VPWR VPWR sky130_fd_sc_hd__decap_3
XFILLER_68_133 VGND VGND VPWR VPWR sky130_fd_sc_hd__decap_3
XFILLER_68_144 VGND VGND VPWR VPWR sky130_fd_sc_hd__decap_3
XFILLER_84_604 VGND VGND VPWR VPWR sky130_fd_sc_hd__decap_3
X_5093_ _5577_/S _3867_/X _5658_/C _5092_/X _3346_/A VGND VGND VPWR VPWR _5093_/X
+ sky130_fd_sc_hd__o32a_2
X_4113_ _7364_/Q _4196_/A2 _4112_/X _4188_/C1 VGND VGND VPWR VPWR _4113_/X sky130_fd_sc_hd__a211o_2
XTAP_TAPCELL_ROW_110_1569 VGND VPWR sky130_fd_sc_hd__tapvpwrvgnd_1
XFILLER_68_188 VGND VGND VPWR VPWR sky130_fd_sc_hd__decap_3
XFILLER_69_689 VGND VGND VPWR VPWR sky130_fd_sc_hd__decap_3
XFILLER_96_486 VGND VGND VPWR VPWR sky130_fd_sc_hd__decap_3
XFILLER_56_339 VGND VGND VPWR VPWR sky130_fd_sc_hd__decap_3
X_4044_ _7277_/Q _4437_/A2 _4041_/X _4043_/X VGND VGND VPWR VPWR _4044_/X sky130_fd_sc_hd__a211o_2
XFILLER_37_553 VGND VGND VPWR VPWR sky130_fd_sc_hd__decap_3
XFILLER_52_501 VGND VGND VPWR VPWR sky130_fd_sc_hd__decap_3
XFILLER_64_361 VGND VGND VPWR VPWR sky130_fd_sc_hd__decap_3
XFILLER_83_169 VGND VGND VPWR VPWR sky130_fd_sc_hd__fill_1
XFILLER_24_203 VGND VGND VPWR VPWR sky130_fd_sc_hd__decap_3
XFILLER_64_383 VGND VGND VPWR VPWR sky130_fd_sc_hd__decap_3
XFILLER_64_394 VGND VGND VPWR VPWR sky130_fd_sc_hd__decap_3
XFILLER_91_180 VGND VGND VPWR VPWR sky130_fd_sc_hd__decap_3
XTAP_TAPCELL_ROW_65_1037 VGND VPWR sky130_fd_sc_hd__tapvpwrvgnd_1
XTAP_TAPCELL_ROW_65_1026 VGND VPWR sky130_fd_sc_hd__tapvpwrvgnd_1
XFILLER_24_269 VGND VGND VPWR VPWR sky130_fd_sc_hd__decap_3
XFILLER_33_39 VGND VGND VPWR VPWR sky130_fd_sc_hd__decap_3
X_4946_ _4946_/A0 _4945_/X _4946_/S VGND VGND VPWR VPWR _7265_/D sky130_fd_sc_hd__mux2_2
X_4877_ _4799_/A _5663_/C _3753_/X _3346_/A VGND VGND VPWR VPWR _4877_/X sky130_fd_sc_hd__o211a_2
XFILLER_20_453 VGND VGND VPWR VPWR sky130_fd_sc_hd__decap_3
X_6616_ _6616_/A VGND VGND VPWR VPWR _6616_/Y sky130_fd_sc_hd__inv_2
X_3828_ _6926_/Q _3828_/A2 _3913_/A2 _6790_/Q _3827_/X VGND VGND VPWR VPWR _3828_/X
+ sky130_fd_sc_hd__a221o_2
X_6547_ _6547_/A VGND VGND VPWR VPWR _6547_/Y sky130_fd_sc_hd__inv_2
XFILLER_106_514 VGND VGND VPWR VPWR sky130_fd_sc_hd__decap_3
X_3759_ _6797_/Q _3922_/A2 _3858_/B1 _6885_/Q VGND VGND VPWR VPWR _3759_/X sky130_fd_sc_hd__a22o_2
X_6478_ _6644_/A VGND VGND VPWR VPWR _6478_/Y sky130_fd_sc_hd__inv_2
XTAP_TAPCELL_ROW_76_1166 VGND VPWR sky130_fd_sc_hd__tapvpwrvgnd_1
XFILLER_106_569 VGND VGND VPWR VPWR sky130_fd_sc_hd__fill_1
X_5429_ _7119_/Q _4470_/X _5429_/S VGND VGND VPWR VPWR _7119_/D sky130_fd_sc_hd__mux2_2
XFILLER_58_47 VGND VGND VPWR VPWR sky130_fd_sc_hd__fill_1
XFILLER_58_58 VGND VGND VPWR VPWR sky130_fd_sc_hd__decap_3
XFILLER_59_122 VGND VGND VPWR VPWR sky130_fd_sc_hd__decap_3
XFILLER_87_431 VGND VGND VPWR VPWR sky130_fd_sc_hd__decap_3
XFILLER_47_317 VGND VGND VPWR VPWR sky130_fd_sc_hd__decap_3
XFILLER_59_188 VGND VGND VPWR VPWR sky130_fd_sc_hd__decap_3
XFILLER_74_103 VGND VGND VPWR VPWR sky130_fd_sc_hd__decap_3
XFILLER_75_615 VGND VGND VPWR VPWR sky130_fd_sc_hd__fill_1
XFILLER_75_626 VGND VGND VPWR VPWR sky130_fd_sc_hd__decap_3
XFILLER_101_285 VGND VGND VPWR VPWR sky130_fd_sc_hd__fill_2
XFILLER_101_296 VGND VGND VPWR VPWR sky130_fd_sc_hd__decap_3
XFILLER_74_147 VGND VGND VPWR VPWR sky130_fd_sc_hd__decap_3
XFILLER_43_501 VGND VGND VPWR VPWR sky130_fd_sc_hd__decap_3
XFILLER_55_361 VGND VGND VPWR VPWR sky130_fd_sc_hd__decap_3
XFILLER_74_46 VGND VGND VPWR VPWR sky130_fd_sc_hd__fill_2
XFILLER_15_225 VGND VGND VPWR VPWR sky130_fd_sc_hd__decap_3
XFILLER_70_320 VGND VGND VPWR VPWR sky130_fd_sc_hd__decap_3
XFILLER_82_180 VGND VGND VPWR VPWR sky130_fd_sc_hd__decap_3
XTAP_TAPCELL_ROW_87_1295 VGND VPWR sky130_fd_sc_hd__tapvpwrvgnd_1
XFILLER_15_258 VGND VGND VPWR VPWR sky130_fd_sc_hd__decap_3
XFILLER_70_353 VGND VGND VPWR VPWR sky130_fd_sc_hd__decap_3
XFILLER_70_397 VGND VGND VPWR VPWR sky130_fd_sc_hd__decap_3
XFILLER_90_23 VGND VGND VPWR VPWR sky130_fd_sc_hd__decap_3
XTAP_TAPCELL_ROW_13_404 VGND VPWR sky130_fd_sc_hd__tapvpwrvgnd_1
XTAP_TAPCELL_ROW_41_746 VGND VPWR sky130_fd_sc_hd__tapvpwrvgnd_1
XFILLER_11_475 VGND VGND VPWR VPWR sky130_fd_sc_hd__fill_1
XFILLER_23_50 VGND VGND VPWR VPWR sky130_fd_sc_hd__decap_3
XFILLER_23_72 VGND VGND VPWR VPWR sky130_fd_sc_hd__decap_3
XFILLER_109_352 VGND VGND VPWR VPWR sky130_fd_sc_hd__decap_3
XFILLER_109_385 VGND VGND VPWR VPWR sky130_fd_sc_hd__decap_3
XFILLER_109_396 VGND VGND VPWR VPWR sky130_fd_sc_hd__decap_3
XFILLER_97_206 VGND VGND VPWR VPWR sky130_fd_sc_hd__decap_3
XFILLER_97_228 VGND VGND VPWR VPWR sky130_fd_sc_hd__decap_3
XFILLER_2_195 VGND VGND VPWR VPWR sky130_fd_sc_hd__fill_1
XFILLER_78_431 VGND VGND VPWR VPWR sky130_fd_sc_hd__decap_3
XFILLER_38_328 VGND VGND VPWR VPWR sky130_fd_sc_hd__fill_1
XFILLER_78_464 VGND VGND VPWR VPWR sky130_fd_sc_hd__decap_3
XFILLER_93_423 VGND VGND VPWR VPWR sky130_fd_sc_hd__fill_1
XFILLER_17_6 VGND VGND VPWR VPWR sky130_fd_sc_hd__decap_3
XFILLER_48_80 VGND VGND VPWR VPWR sky130_fd_sc_hd__fill_1
XFILLER_65_125 VGND VGND VPWR VPWR sky130_fd_sc_hd__fill_1
XFILLER_65_136 VGND VGND VPWR VPWR sky130_fd_sc_hd__decap_3
XTAP_TAPCELL_ROW_49_835 VGND VPWR sky130_fd_sc_hd__tapvpwrvgnd_1
XFILLER_0_32 VGND VGND VPWR VPWR sky130_fd_sc_hd__decap_3
XFILLER_65_169 VGND VGND VPWR VPWR sky130_fd_sc_hd__decap_3
XFILLER_81_629 VGND VGND VPWR VPWR sky130_fd_sc_hd__decap_3
XFILLER_0_65 VGND VGND VPWR VPWR sky130_fd_sc_hd__decap_3
XFILLER_46_383 VGND VGND VPWR VPWR sky130_fd_sc_hd__decap_3
XFILLER_0_98 VGND VGND VPWR VPWR sky130_fd_sc_hd__fill_1
XFILLER_64_90 VGND VGND VPWR VPWR sky130_fd_sc_hd__decap_3
X_4800_ _7002_/Q _4826_/A _7003_/Q VGND VGND VPWR VPWR _4801_/B sky130_fd_sc_hd__a21oi_2
XFILLER_21_228 VGND VGND VPWR VPWR sky130_fd_sc_hd__decap_3
XFILLER_61_364 VGND VGND VPWR VPWR sky130_fd_sc_hd__decap_3
X_4731_ _4731_/A _4731_/B VGND VGND VPWR VPWR _7007_/D sky130_fd_sc_hd__and2_2
X_4662_ _4969_/B _4457_/X _4660_/X _4811_/C _4040_/Y VGND VGND VPWR VPWR _4662_/Y
+ sky130_fd_sc_hd__a221oi_2
XFILLER_9_96 VGND VGND VPWR VPWR sky130_fd_sc_hd__decap_3
X_6401_ _6562_/A VGND VGND VPWR VPWR _6401_/Y sky130_fd_sc_hd__inv_2
X_3613_ _3603_/Y _3606_/X _3612_/X VGND VGND VPWR VPWR _3614_/B sky130_fd_sc_hd__a21oi_2
X_7381_ _7381_/CLK _7381_/D _6661_/Y VGND VGND VPWR VPWR _7381_/Q sky130_fd_sc_hd__dfrtp_2
Xhold903 _7080_/Q VGND VGND VPWR VPWR _7080_/D sky130_fd_sc_hd__dlygate4sd3_1
X_4593_ _7284_/Q _4595_/B VGND VGND VPWR VPWR _7284_/D sky130_fd_sc_hd__and2_2
Xhold914 _5674_/X VGND VGND VPWR VPWR _6687_/D sky130_fd_sc_hd__dlygate4sd3_1
Xhold925 _6714_/Q VGND VGND VPWR VPWR hold925/X sky130_fd_sc_hd__dlygate4sd3_1
Xhold936 _6693_/Q VGND VGND VPWR VPWR hold936/X sky130_fd_sc_hd__dlygate4sd3_1
X_6332_ _6684_/A VGND VGND VPWR VPWR _6332_/Y sky130_fd_sc_hd__inv_2
X_3544_ _3544_/A _3544_/B VGND VGND VPWR VPWR _3635_/A sky130_fd_sc_hd__nor2_2
XFILLER_103_517 VGND VGND VPWR VPWR sky130_fd_sc_hd__decap_3
XFILLER_115_344 VGND VGND VPWR VPWR sky130_fd_sc_hd__decap_3
Xhold969 _5688_/X VGND VGND VPWR VPWR _6694_/D sky130_fd_sc_hd__dlygate4sd3_1
Xhold958 _7315_/Q VGND VGND VPWR VPWR _4528_/A sky130_fd_sc_hd__dlygate4sd3_1
Xhold947 _7020_/Q VGND VGND VPWR VPWR _5615_/A sky130_fd_sc_hd__dlygate4sd3_1
X_6263_ _6385_/A VGND VGND VPWR VPWR _6263_/Y sky130_fd_sc_hd__inv_2
X_3475_ _7248_/Q _4601_/S _3472_/X _3474_/X VGND VGND VPWR VPWR _3475_/Y sky130_fd_sc_hd__a211oi_2
XFILLER_69_420 VGND VGND VPWR VPWR sky130_fd_sc_hd__decap_3
XFILLER_88_217 VGND VGND VPWR VPWR sky130_fd_sc_hd__decap_3
XFILLER_111_561 VGND VGND VPWR VPWR sky130_fd_sc_hd__decap_3
XFILLER_69_464 VGND VGND VPWR VPWR sky130_fd_sc_hd__decap_3
X_5145_ _5145_/A _3500_/Y VGND VGND VPWR VPWR _5145_/X sky130_fd_sc_hd__or2b_2
XFILLER_56_125 VGND VGND VPWR VPWR sky130_fd_sc_hd__fill_1
XFILLER_84_456 VGND VGND VPWR VPWR sky130_fd_sc_hd__decap_3
XFILLER_96_283 VGND VGND VPWR VPWR sky130_fd_sc_hd__decap_3
XFILLER_44_309 VGND VGND VPWR VPWR sky130_fd_sc_hd__decap_3
XFILLER_71_106 VGND VGND VPWR VPWR sky130_fd_sc_hd__decap_3
XFILLER_84_489 VGND VGND VPWR VPWR sky130_fd_sc_hd__decap_3
XFILLER_37_361 VGND VGND VPWR VPWR sky130_fd_sc_hd__decap_3
XFILLER_37_383 VGND VGND VPWR VPWR sky130_fd_sc_hd__decap_3
XFILLER_44_16 VGND VGND VPWR VPWR sky130_fd_sc_hd__decap_3
XFILLER_65_670 VGND VGND VPWR VPWR sky130_fd_sc_hd__fill_2
XFILLER_44_38 VGND VGND VPWR VPWR sky130_fd_sc_hd__decap_3
XFILLER_44_49 VGND VGND VPWR VPWR sky130_fd_sc_hd__decap_3
XFILLER_52_342 VGND VGND VPWR VPWR sky130_fd_sc_hd__decap_3
XFILLER_64_191 VGND VGND VPWR VPWR sky130_fd_sc_hd__decap_3
XFILLER_12_206 VGND VGND VPWR VPWR sky130_fd_sc_hd__decap_3
XFILLER_40_504 VGND VGND VPWR VPWR sky130_fd_sc_hd__fill_1
XFILLER_100_44 VGND VGND VPWR VPWR sky130_fd_sc_hd__decap_3
XFILLER_40_537 VGND VGND VPWR VPWR sky130_fd_sc_hd__fill_1
XFILLER_40_559 VGND VGND VPWR VPWR sky130_fd_sc_hd__fill_2
X_4929_ _4908_/B _4928_/Y _4975_/A VGND VGND VPWR VPWR _4929_/Y sky130_fd_sc_hd__o21ai_2
XFILLER_100_88 VGND VGND VPWR VPWR sky130_fd_sc_hd__decap_3
XFILLER_60_15 VGND VGND VPWR VPWR sky130_fd_sc_hd__decap_3
XFILLER_106_300 VGND VGND VPWR VPWR sky130_fd_sc_hd__decap_3
XFILLER_4_449 VGND VGND VPWR VPWR sky130_fd_sc_hd__decap_3
XFILLER_109_86 VGND VGND VPWR VPWR sky130_fd_sc_hd__decap_3
XFILLER_69_24 VGND VGND VPWR VPWR sky130_fd_sc_hd__decap_3
XFILLER_69_46 VGND VGND VPWR VPWR sky130_fd_sc_hd__decap_3
XFILLER_69_57 VGND VGND VPWR VPWR sky130_fd_sc_hd__decap_3
XFILLER_106_377 VGND VGND VPWR VPWR sky130_fd_sc_hd__decap_3
XFILLER_79_228 VGND VGND VPWR VPWR sky130_fd_sc_hd__decap_3
XFILLER_79_239 VGND VGND VPWR VPWR sky130_fd_sc_hd__decap_3
XFILLER_102_572 VGND VGND VPWR VPWR sky130_fd_sc_hd__decap_3
XFILLER_85_23 VGND VGND VPWR VPWR sky130_fd_sc_hd__decap_3
XFILLER_94_209 VGND VGND VPWR VPWR sky130_fd_sc_hd__decap_3
XFILLER_75_445 VGND VGND VPWR VPWR sky130_fd_sc_hd__decap_3
XFILLER_85_45 VGND VGND VPWR VPWR sky130_fd_sc_hd__decap_3
XTAP_TAPCELL_ROW_89_1324 VGND VPWR sky130_fd_sc_hd__tapvpwrvgnd_1
XFILLER_47_158 VGND VGND VPWR VPWR sky130_fd_sc_hd__decap_3
XFILLER_47_169 VGND VGND VPWR VPWR sky130_fd_sc_hd__decap_3
XFILLER_75_467 VGND VGND VPWR VPWR sky130_fd_sc_hd__decap_3
XFILLER_85_78 VGND VGND VPWR VPWR sky130_fd_sc_hd__decap_3
XTAP_TAPCELL_ROW_46_805 VGND VPWR sky130_fd_sc_hd__tapvpwrvgnd_1
XFILLER_18_94 VGND VGND VPWR VPWR sky130_fd_sc_hd__decap_3
XFILLER_62_117 VGND VGND VPWR VPWR sky130_fd_sc_hd__fill_1
XFILLER_62_128 VGND VGND VPWR VPWR sky130_fd_sc_hd__decap_3
XFILLER_90_437 VGND VGND VPWR VPWR sky130_fd_sc_hd__decap_3
XFILLER_16_578 VGND VGND VPWR VPWR sky130_fd_sc_hd__fill_2
XFILLER_16_589 VGND VGND VPWR VPWR sky130_fd_sc_hd__decap_3
XFILLER_43_386 VGND VGND VPWR VPWR sky130_fd_sc_hd__decap_3
XFILLER_70_150 VGND VGND VPWR VPWR sky130_fd_sc_hd__fill_2
XFILLER_70_172 VGND VGND VPWR VPWR sky130_fd_sc_hd__decap_3
XFILLER_71_673 VGND VGND VPWR VPWR sky130_fd_sc_hd__decap_3
XTAP_TAPCELL_ROW_26_562 VGND VPWR sky130_fd_sc_hd__tapvpwrvgnd_1
XFILLER_34_60 VGND VGND VPWR VPWR sky130_fd_sc_hd__decap_3
XFILLER_116_119 VGND VGND VPWR VPWR sky130_fd_sc_hd__fill_1
XFILLER_7_265 VGND VGND VPWR VPWR sky130_fd_sc_hd__decap_3
XFILLER_109_160 VGND VGND VPWR VPWR sky130_fd_sc_hd__decap_3
XFILLER_109_182 VGND VGND VPWR VPWR sky130_fd_sc_hd__decap_3
XFILLER_50_70 VGND VGND VPWR VPWR sky130_fd_sc_hd__decap_3
XFILLER_7_287 VGND VGND VPWR VPWR sky130_fd_sc_hd__decap_3
XFILLER_98_504 VGND VGND VPWR VPWR sky130_fd_sc_hd__decap_3
XFILLER_98_548 VGND VGND VPWR VPWR sky130_fd_sc_hd__decap_3
XFILLER_112_347 VGND VGND VPWR VPWR sky130_fd_sc_hd__decap_3
XFILLER_100_509 VGND VGND VPWR VPWR sky130_fd_sc_hd__decap_3
XFILLER_38_103 VGND VGND VPWR VPWR sky130_fd_sc_hd__decap_3
XFILLER_59_90 VGND VGND VPWR VPWR sky130_fd_sc_hd__decap_3
XFILLER_85_209 VGND VGND VPWR VPWR sky130_fd_sc_hd__decap_3
XFILLER_15_3 VGND VGND VPWR VPWR sky130_fd_sc_hd__decap_3
XFILLER_38_136 VGND VGND VPWR VPWR sky130_fd_sc_hd__decap_3
XFILLER_66_445 VGND VGND VPWR VPWR sky130_fd_sc_hd__decap_3
XFILLER_93_220 VGND VGND VPWR VPWR sky130_fd_sc_hd__decap_3
XFILLER_26_309 VGND VGND VPWR VPWR sky130_fd_sc_hd__decap_3
XFILLER_38_147 VGND VGND VPWR VPWR sky130_fd_sc_hd__decap_3
XFILLER_93_253 VGND VGND VPWR VPWR sky130_fd_sc_hd__decap_3
X_6950_ _6968_/CLK _6950_/D VGND VGND VPWR VPWR _6950_/Q sky130_fd_sc_hd__dfxtp_2
XFILLER_47_670 VGND VGND VPWR VPWR sky130_fd_sc_hd__fill_2
XFILLER_53_139 VGND VGND VPWR VPWR sky130_fd_sc_hd__decap_3
XFILLER_81_437 VGND VGND VPWR VPWR sky130_fd_sc_hd__decap_3
XTAP_TAPCELL_ROW_109_1560 VGND VPWR sky130_fd_sc_hd__tapvpwrvgnd_1
XFILLER_34_342 VGND VGND VPWR VPWR sky130_fd_sc_hd__decap_3
XFILLER_46_191 VGND VGND VPWR VPWR sky130_fd_sc_hd__decap_3
XFILLER_62_640 VGND VGND VPWR VPWR sky130_fd_sc_hd__decap_3
X_6881_ _7384_/CLK _6881_/D VGND VGND VPWR VPWR _6881_/Q sky130_fd_sc_hd__dfxtp_2
XFILLER_61_172 VGND VGND VPWR VPWR sky130_fd_sc_hd__decap_3
XPHY_EDGE_ROW_101_Left_218 VGND VGND VPWR VPWR sky130_fd_sc_hd__decap_3
XFILLER_30_592 VGND VGND VPWR VPWR sky130_fd_sc_hd__decap_3
XFILLER_107_119 VGND VGND VPWR VPWR sky130_fd_sc_hd__fill_2
XFILLER_30_18 VGND VGND VPWR VPWR sky130_fd_sc_hd__fill_2
XFILLER_30_29 VGND VGND VPWR VPWR sky130_fd_sc_hd__fill_2
X_4645_ _4633_/X _4903_/B _4644_/X _4096_/A VGND VGND VPWR VPWR _4646_/B sky130_fd_sc_hd__o211a_2
XFILLER_116_620 VGND VGND VPWR VPWR sky130_fd_sc_hd__decap_3
X_7364_ _7364_/CLK _7364_/D _6644_/Y VGND VGND VPWR VPWR _7364_/Q sky130_fd_sc_hd__dfrtp_2
Xhold700 _6946_/Q VGND VGND VPWR VPWR _6946_/D sky130_fd_sc_hd__dlygate4sd3_1
Xhold711 _6757_/Q VGND VGND VPWR VPWR _6757_/D sky130_fd_sc_hd__dlygate4sd3_1
Xhold722 _6821_/Q VGND VGND VPWR VPWR _6821_/D sky130_fd_sc_hd__dlygate4sd3_1
Xhold733 _6854_/Q VGND VGND VPWR VPWR _6854_/D sky130_fd_sc_hd__dlygate4sd3_1
Xhold744 _6827_/Q VGND VGND VPWR VPWR _6827_/D sky130_fd_sc_hd__dlygate4sd3_1
Xhold755 _6964_/Q VGND VGND VPWR VPWR _6964_/D sky130_fd_sc_hd__dlygate4sd3_1
X_6315_ _6637_/A VGND VGND VPWR VPWR _6315_/Y sky130_fd_sc_hd__inv_2
X_3527_ _3527_/A _3427_/B VGND VGND VPWR VPWR _4614_/A sky130_fd_sc_hd__nor2b_2
XFILLER_103_314 VGND VGND VPWR VPWR sky130_fd_sc_hd__decap_3
XFILLER_89_537 VGND VGND VPWR VPWR sky130_fd_sc_hd__decap_3
X_7295_ _7359_/CLK _7295_/D _6575_/Y VGND VGND VPWR VPWR _7295_/Q sky130_fd_sc_hd__dfrtp_2
Xhold766 _6952_/Q VGND VGND VPWR VPWR _6952_/D sky130_fd_sc_hd__dlygate4sd3_1
Xhold777 _6882_/Q VGND VGND VPWR VPWR _6882_/D sky130_fd_sc_hd__dlygate4sd3_1
Xhold788 _6920_/Q VGND VGND VPWR VPWR _6920_/D sky130_fd_sc_hd__dlygate4sd3_1
XTAP_TAPCELL_ROW_73_1125 VGND VPWR sky130_fd_sc_hd__tapvpwrvgnd_1
XFILLER_103_358 VGND VGND VPWR VPWR sky130_fd_sc_hd__decap_3
XFILLER_39_16 VGND VGND VPWR VPWR sky130_fd_sc_hd__fill_2
Xhold799 _6928_/Q VGND VGND VPWR VPWR _6928_/D sky130_fd_sc_hd__dlygate4sd3_1
X_3458_ _3544_/A _3506_/B VGND VGND VPWR VPWR _3458_/Y sky130_fd_sc_hd__nor2_2
XPHY_EDGE_ROW_110_Left_227 VGND VGND VPWR VPWR sky130_fd_sc_hd__decap_3
XFILLER_69_261 VGND VGND VPWR VPWR sky130_fd_sc_hd__decap_3
X_3389_ _7347_/Q _4338_/B1 _3384_/X _4248_/A VGND VGND VPWR VPWR _3389_/X sky130_fd_sc_hd__a211o_2
XFILLER_111_391 VGND VGND VPWR VPWR sky130_fd_sc_hd__fill_1
XFILLER_29_125 VGND VGND VPWR VPWR sky130_fd_sc_hd__decap_3
XFILLER_57_445 VGND VGND VPWR VPWR sky130_fd_sc_hd__decap_3
X_5128_ _3733_/C _3904_/Y _4677_/B VGND VGND VPWR VPWR _5128_/Y sky130_fd_sc_hd__a21oi_2
XFILLER_29_158 VGND VGND VPWR VPWR sky130_fd_sc_hd__decap_3
XFILLER_29_169 VGND VGND VPWR VPWR sky130_fd_sc_hd__decap_3
XFILLER_72_404 VGND VGND VPWR VPWR sky130_fd_sc_hd__decap_3
XFILLER_84_231 VGND VGND VPWR VPWR sky130_fd_sc_hd__decap_3
XFILLER_84_253 VGND VGND VPWR VPWR sky130_fd_sc_hd__fill_2
XFILLER_84_264 VGND VGND VPWR VPWR sky130_fd_sc_hd__decap_3
XFILLER_44_128 VGND VGND VPWR VPWR sky130_fd_sc_hd__decap_3
XFILLER_55_37 VGND VGND VPWR VPWR sky130_fd_sc_hd__fill_1
XFILLER_55_48 VGND VGND VPWR VPWR sky130_fd_sc_hd__fill_1
XFILLER_57_489 VGND VGND VPWR VPWR sky130_fd_sc_hd__fill_1
XFILLER_84_297 VGND VGND VPWR VPWR sky130_fd_sc_hd__decap_3
X_5059_ _4799_/A _3859_/X _5662_/B VGND VGND VPWR VPWR _5059_/X sky130_fd_sc_hd__a21o_2
XFILLER_25_320 VGND VGND VPWR VPWR sky130_fd_sc_hd__decap_3
XFILLER_53_651 VGND VGND VPWR VPWR sky130_fd_sc_hd__fill_2
XFILLER_72_448 VGND VGND VPWR VPWR sky130_fd_sc_hd__decap_3
XFILLER_111_43 VGND VGND VPWR VPWR sky130_fd_sc_hd__decap_3
XFILLER_25_364 VGND VGND VPWR VPWR sky130_fd_sc_hd__decap_3
XFILLER_52_150 VGND VGND VPWR VPWR sky130_fd_sc_hd__decap_3
XTAP_TAPCELL_ROW_84_1265 VGND VPWR sky130_fd_sc_hd__tapvpwrvgnd_1
XTAP_TAPCELL_ROW_84_1254 VGND VPWR sky130_fd_sc_hd__tapvpwrvgnd_1
XFILLER_111_98 VGND VGND VPWR VPWR sky130_fd_sc_hd__fill_2
XFILLER_13_548 VGND VGND VPWR VPWR sky130_fd_sc_hd__decap_3
XFILLER_40_312 VGND VGND VPWR VPWR sky130_fd_sc_hd__decap_3
XFILLER_71_25 VGND VGND VPWR VPWR sky130_fd_sc_hd__decap_3
XFILLER_71_47 VGND VGND VPWR VPWR sky130_fd_sc_hd__fill_1
XFILLER_80_492 VGND VGND VPWR VPWR sky130_fd_sc_hd__decap_3
XTAP_TAPCELL_ROW_23_532 VGND VPWR sky130_fd_sc_hd__tapvpwrvgnd_1
XFILLER_40_345 VGND VGND VPWR VPWR sky130_fd_sc_hd__decap_3
XFILLER_71_69 VGND VGND VPWR VPWR sky130_fd_sc_hd__decap_3
XTAP_TAPCELL_ROW_51_863 VGND VPWR sky130_fd_sc_hd__tapvpwrvgnd_1
XPHY_EDGE_ROW_109_Right_109 VGND VGND VPWR VPWR sky130_fd_sc_hd__decap_3
XFILLER_106_141 VGND VGND VPWR VPWR sky130_fd_sc_hd__decap_3
XFILLER_107_653 VGND VGND VPWR VPWR sky130_fd_sc_hd__decap_3
XFILLER_106_174 VGND VGND VPWR VPWR sky130_fd_sc_hd__fill_1
XFILLER_20_62 VGND VGND VPWR VPWR sky130_fd_sc_hd__decap_3
XFILLER_4_279 VGND VGND VPWR VPWR sky130_fd_sc_hd__decap_3
XFILLER_96_11 VGND VGND VPWR VPWR sky130_fd_sc_hd__decap_3
XTAP_TAPCELL_ROW_95_1394 VGND VPWR sky130_fd_sc_hd__tapvpwrvgnd_1
XFILLER_95_529 VGND VGND VPWR VPWR sky130_fd_sc_hd__decap_3
XFILLER_96_77 VGND VGND VPWR VPWR sky130_fd_sc_hd__decap_3
XFILLER_29_60 VGND VGND VPWR VPWR sky130_fd_sc_hd__decap_3
XFILLER_48_445 VGND VGND VPWR VPWR sky130_fd_sc_hd__decap_3
XFILLER_88_581 VGND VGND VPWR VPWR sky130_fd_sc_hd__decap_3
XFILLER_88_592 VGND VGND VPWR VPWR sky130_fd_sc_hd__decap_3
XFILLER_29_93 VGND VGND VPWR VPWR sky130_fd_sc_hd__decap_3
XFILLER_75_231 VGND VGND VPWR VPWR sky130_fd_sc_hd__decap_3
XTAP_TAPCELL_ROW_59_963 VGND VPWR sky130_fd_sc_hd__tapvpwrvgnd_1
XFILLER_35_128 VGND VGND VPWR VPWR sky130_fd_sc_hd__decap_3
XFILLER_63_426 VGND VGND VPWR VPWR sky130_fd_sc_hd__decap_3
XFILLER_75_297 VGND VGND VPWR VPWR sky130_fd_sc_hd__decap_3
XFILLER_90_201 VGND VGND VPWR VPWR sky130_fd_sc_hd__decap_3
Xplace404 _4534_/S VGND VGND VPWR VPWR _4507_/S sky130_fd_sc_hd__buf_2
XFILLER_16_331 VGND VGND VPWR VPWR sky130_fd_sc_hd__decap_3
XFILLER_16_342 VGND VGND VPWR VPWR sky130_fd_sc_hd__decap_3
XFILLER_90_234 VGND VGND VPWR VPWR sky130_fd_sc_hd__decap_3
Xplace415 _4419_/B1 VGND VGND VPWR VPWR _4437_/B1 sky130_fd_sc_hd__buf_2
Xplace426 _3947_/S VGND VGND VPWR VPWR _3945_/S sky130_fd_sc_hd__buf_2
Xplace437 _4348_/A2 VGND VGND VPWR VPWR _4339_/B1 sky130_fd_sc_hd__buf_2
XTAP_TAPCELL_ROW_3_290 VGND VPWR sky130_fd_sc_hd__tapvpwrvgnd_1
XFILLER_45_70 VGND VGND VPWR VPWR sky130_fd_sc_hd__decap_3
XFILLER_90_289 VGND VGND VPWR VPWR sky130_fd_sc_hd__decap_3
Xplace448 _5647_/A VGND VGND VPWR VPWR _4960_/A sky130_fd_sc_hd__buf_2
Xplace459 _3327_/A VGND VGND VPWR VPWR _3371_/A sky130_fd_sc_hd__buf_2
XFILLER_43_172 VGND VGND VPWR VPWR sky130_fd_sc_hd__decap_3
XFILLER_71_481 VGND VGND VPWR VPWR sky130_fd_sc_hd__decap_3
XFILLER_84_6 VGND VGND VPWR VPWR sky130_fd_sc_hd__decap_3
XANTENNA_2 _5642_/B VGND VGND VPWR VPWR sky130_fd_sc_hd__diode_2
X_4430_ _7239_/Q _4430_/A2 _4430_/B1 _7175_/Q _4429_/X VGND VGND VPWR VPWR _4430_/X
+ sky130_fd_sc_hd__a221o_2
XFILLER_6_64 VGND VGND VPWR VPWR sky130_fd_sc_hd__decap_3
XFILLER_112_100 VGND VGND VPWR VPWR sky130_fd_sc_hd__fill_2
X_4361_ _4361_/A _4619_/B _5101_/B _5073_/A VGND VGND VPWR VPWR _4361_/X sky130_fd_sc_hd__and4_2
XFILLER_98_312 VGND VGND VPWR VPWR sky130_fd_sc_hd__decap_3
XFILLER_3_290 VGND VGND VPWR VPWR sky130_fd_sc_hd__decap_3
X_7080_ _7330_/CLK _7080_/D _6360_/Y VGND VGND VPWR VPWR _7080_/Q sky130_fd_sc_hd__dfrtp_2
X_4292_ _4292_/A _4292_/B _4292_/C VGND VGND VPWR VPWR _4292_/X sky130_fd_sc_hd__and3_2
X_3312_ _3386_/A _4467_/A _3519_/B _3310_/Y _5671_/A VGND VGND VPWR VPWR _5646_/A
+ sky130_fd_sc_hd__a311o_2
XFILLER_58_209 VGND VGND VPWR VPWR sky130_fd_sc_hd__decap_3
XFILLER_98_389 VGND VGND VPWR VPWR sky130_fd_sc_hd__decap_3
XFILLER_39_423 VGND VGND VPWR VPWR sky130_fd_sc_hd__decap_3
XFILLER_66_242 VGND VGND VPWR VPWR sky130_fd_sc_hd__decap_3
XFILLER_66_253 VGND VGND VPWR VPWR sky130_fd_sc_hd__decap_3
XFILLER_54_415 VGND VGND VPWR VPWR sky130_fd_sc_hd__decap_3
XFILLER_26_139 VGND VGND VPWR VPWR sky130_fd_sc_hd__fill_1
XFILLER_54_448 VGND VGND VPWR VPWR sky130_fd_sc_hd__decap_3
XFILLER_54_459 VGND VGND VPWR VPWR sky130_fd_sc_hd__decap_3
XFILLER_81_223 VGND VGND VPWR VPWR sky130_fd_sc_hd__fill_1
XFILLER_81_234 VGND VGND VPWR VPWR sky130_fd_sc_hd__decap_3
X_6933_ _7198_/CLK _6933_/D VGND VGND VPWR VPWR _6933_/Q sky130_fd_sc_hd__dfxtp_2
XFILLER_34_161 VGND VGND VPWR VPWR sky130_fd_sc_hd__decap_3
XFILLER_35_673 VGND VGND VPWR VPWR sky130_fd_sc_hd__fill_2
XFILLER_81_278 VGND VGND VPWR VPWR sky130_fd_sc_hd__fill_2
X_6864_ _7198_/CLK _6864_/D VGND VGND VPWR VPWR _6864_/Q sky130_fd_sc_hd__dfxtp_2
XFILLER_22_312 VGND VGND VPWR VPWR sky130_fd_sc_hd__fill_2
XFILLER_22_323 VGND VGND VPWR VPWR sky130_fd_sc_hd__fill_2
XFILLER_34_194 VGND VGND VPWR VPWR sky130_fd_sc_hd__fill_2
XFILLER_62_492 VGND VGND VPWR VPWR sky130_fd_sc_hd__decap_3
XFILLER_22_345 VGND VGND VPWR VPWR sky130_fd_sc_hd__decap_3
X_6795_ _7390_/CLK _6795_/D VGND VGND VPWR VPWR _6795_/Q sky130_fd_sc_hd__dfxtp_2
XFILLER_22_389 VGND VGND VPWR VPWR sky130_fd_sc_hd__decap_3
XFILLER_41_17 VGND VGND VPWR VPWR sky130_fd_sc_hd__decap_3
XFILLER_41_39 VGND VGND VPWR VPWR sky130_fd_sc_hd__decap_3
XFILLER_50_687 VGND VGND VPWR VPWR sky130_fd_sc_hd__decap_3
X_4628_ _4628_/A VGND VGND VPWR VPWR _4629_/A sky130_fd_sc_hd__inv_2
XFILLER_103_100 VGND VGND VPWR VPWR sky130_fd_sc_hd__decap_3
XFILLER_104_612 VGND VGND VPWR VPWR sky130_fd_sc_hd__decap_3
XFILLER_116_461 VGND VGND VPWR VPWR sky130_fd_sc_hd__decap_3
XFILLER_116_483 VGND VGND VPWR VPWR sky130_fd_sc_hd__decap_3
XFILLER_1_205 VGND VGND VPWR VPWR sky130_fd_sc_hd__decap_3
X_7347_ _7351_/CLK _7347_/D _6627_/Y VGND VGND VPWR VPWR _7347_/Q sky130_fd_sc_hd__dfrtp_2
X_4559_ _4559_/A _4567_/B VGND VGND VPWR VPWR _7301_/D sky130_fd_sc_hd__and2_2
XFILLER_103_122 VGND VGND VPWR VPWR sky130_fd_sc_hd__fill_2
XFILLER_104_656 VGND VGND VPWR VPWR sky130_fd_sc_hd__fill_1
XFILLER_1_249 VGND VGND VPWR VPWR sky130_fd_sc_hd__decap_3
XFILLER_89_334 VGND VGND VPWR VPWR sky130_fd_sc_hd__fill_2
X_7278_ _7340_/CLK _7278_/D _6558_/Y VGND VGND VPWR VPWR _7278_/Q sky130_fd_sc_hd__dfrtp_2
Xhold596 _6884_/Q VGND VGND VPWR VPWR _6884_/D sky130_fd_sc_hd__dlygate4sd3_1
XFILLER_77_529 VGND VGND VPWR VPWR sky130_fd_sc_hd__decap_3
XFILLER_103_199 VGND VGND VPWR VPWR sky130_fd_sc_hd__decap_3
XFILLER_57_231 VGND VGND VPWR VPWR sky130_fd_sc_hd__decap_3
XFILLER_66_47 VGND VGND VPWR VPWR sky130_fd_sc_hd__fill_1
XFILLER_85_540 VGND VGND VPWR VPWR sky130_fd_sc_hd__decap_3
XFILLER_57_275 VGND VGND VPWR VPWR sky130_fd_sc_hd__decap_3
XFILLER_72_212 VGND VGND VPWR VPWR sky130_fd_sc_hd__decap_3
XTAP_TAPCELL_ROW_56_922 VGND VPWR sky130_fd_sc_hd__tapvpwrvgnd_1
XFILLER_17_128 VGND VGND VPWR VPWR sky130_fd_sc_hd__decap_3
XFILLER_72_234 VGND VGND VPWR VPWR sky130_fd_sc_hd__decap_3
XFILLER_60_418 VGND VGND VPWR VPWR sky130_fd_sc_hd__fill_2
XFILLER_72_256 VGND VGND VPWR VPWR sky130_fd_sc_hd__decap_3
XFILLER_72_289 VGND VGND VPWR VPWR sky130_fd_sc_hd__decap_3
XFILLER_82_35 VGND VGND VPWR VPWR sky130_fd_sc_hd__decap_3
XFILLER_13_312 VGND VGND VPWR VPWR sky130_fd_sc_hd__decap_3
XFILLER_25_172 VGND VGND VPWR VPWR sky130_fd_sc_hd__decap_3
XFILLER_53_481 VGND VGND VPWR VPWR sky130_fd_sc_hd__decap_3
XFILLER_82_79 VGND VGND VPWR VPWR sky130_fd_sc_hd__decap_3
XFILLER_15_51 VGND VGND VPWR VPWR sky130_fd_sc_hd__decap_3
XFILLER_40_153 VGND VGND VPWR VPWR sky130_fd_sc_hd__decap_3
XFILLER_9_305 VGND VGND VPWR VPWR sky130_fd_sc_hd__decap_3
XFILLER_40_186 VGND VGND VPWR VPWR sky130_fd_sc_hd__decap_3
XFILLER_9_349 VGND VGND VPWR VPWR sky130_fd_sc_hd__decap_3
XFILLER_40_197 VGND VGND VPWR VPWR sky130_fd_sc_hd__decap_3
XTAP_TAPCELL_ROW_97_1412 VGND VPWR sky130_fd_sc_hd__tapvpwrvgnd_1
XFILLER_114_409 VGND VGND VPWR VPWR sky130_fd_sc_hd__decap_3
XFILLER_107_461 VGND VGND VPWR VPWR sky130_fd_sc_hd__decap_3
XFILLER_95_315 VGND VGND VPWR VPWR sky130_fd_sc_hd__decap_3
XFILLER_110_648 VGND VGND VPWR VPWR sky130_fd_sc_hd__decap_3
XFILLER_95_337 VGND VGND VPWR VPWR sky130_fd_sc_hd__decap_3
XFILLER_48_253 VGND VGND VPWR VPWR sky130_fd_sc_hd__decap_3
XFILLER_76_584 VGND VGND VPWR VPWR sky130_fd_sc_hd__decap_3
XFILLER_76_595 VGND VGND VPWR VPWR sky130_fd_sc_hd__fill_1
XFILLER_48_297 VGND VGND VPWR VPWR sky130_fd_sc_hd__decap_3
XFILLER_56_80 VGND VGND VPWR VPWR sky130_fd_sc_hd__decap_3
XFILLER_56_91 VGND VGND VPWR VPWR sky130_fd_sc_hd__decap_3
XFILLER_91_554 VGND VGND VPWR VPWR sky130_fd_sc_hd__decap_3
XFILLER_16_150 VGND VGND VPWR VPWR sky130_fd_sc_hd__decap_3
XFILLER_17_673 VGND VGND VPWR VPWR sky130_fd_sc_hd__fill_2
XFILLER_63_278 VGND VGND VPWR VPWR sky130_fd_sc_hd__fill_2
XFILLER_16_183 VGND VGND VPWR VPWR sky130_fd_sc_hd__decap_3
XFILLER_44_492 VGND VGND VPWR VPWR sky130_fd_sc_hd__fill_1
Xplace289 _3906_/B1 VGND VGND VPWR VPWR _3826_/A2 sky130_fd_sc_hd__buf_2
Xplace278 _3926_/A2 VGND VGND VPWR VPWR _3859_/A2 sky130_fd_sc_hd__buf_2
Xplace267 _5660_/A VGND VGND VPWR VPWR _3682_/A sky130_fd_sc_hd__buf_2
XFILLER_31_131 VGND VGND VPWR VPWR sky130_fd_sc_hd__decap_3
XFILLER_82_3 VGND VGND VPWR VPWR sky130_fd_sc_hd__decap_3
X_6580_ _6610_/A VGND VGND VPWR VPWR _6580_/Y sky130_fd_sc_hd__inv_2
X_5600_ _5600_/A _5611_/B VGND VGND VPWR VPWR _7027_/D sky130_fd_sc_hd__and2_2
X_3792_ hold960/X _4466_/A _4961_/A VGND VGND VPWR VPWR _7392_/D sky130_fd_sc_hd__a21o_2
XFILLER_31_197 VGND VGND VPWR VPWR sky130_fd_sc_hd__decap_3
XFILLER_8_371 VGND VGND VPWR VPWR sky130_fd_sc_hd__decap_3
X_7201_ _7361_/CLK _7201_/D _6481_/Y VGND VGND VPWR VPWR _7201_/Q sky130_fd_sc_hd__dfrtp_2
X_4413_ _4413_/A VGND VGND VPWR VPWR _4787_/A sky130_fd_sc_hd__inv_2
XFILLER_113_420 VGND VGND VPWR VPWR sky130_fd_sc_hd__decap_3
X_7132_ _7294_/CLK _7132_/D _6412_/Y VGND VGND VPWR VPWR _7132_/Q sky130_fd_sc_hd__dfrtp_2
X_4344_ _4365_/A _4365_/B _4365_/C VGND VGND VPWR VPWR _4345_/B sky130_fd_sc_hd__a21bo_2
XFILLER_101_604 VGND VGND VPWR VPWR sky130_fd_sc_hd__decap_3
X_7063_ clkload9/A _7063_/D _6343_/Y VGND VGND VPWR VPWR _7063_/Q sky130_fd_sc_hd__dfrtp_2
XTAP_TAPCELL_ROW_6_319 VGND VPWR sky130_fd_sc_hd__tapvpwrvgnd_1
XFILLER_99_665 VGND VGND VPWR VPWR sky130_fd_sc_hd__decap_3
XFILLER_100_114 VGND VGND VPWR VPWR sky130_fd_sc_hd__decap_3
XFILLER_101_626 VGND VGND VPWR VPWR sky130_fd_sc_hd__decap_3
XFILLER_86_348 VGND VGND VPWR VPWR sky130_fd_sc_hd__decap_3
X_4275_ _4275_/A _4274_/Y VGND VGND VPWR VPWR _4620_/C sky130_fd_sc_hd__nor2b_2
XFILLER_98_197 VGND VGND VPWR VPWR sky130_fd_sc_hd__fill_1
XFILLER_100_147 VGND VGND VPWR VPWR sky130_fd_sc_hd__decap_3
XFILLER_39_253 VGND VGND VPWR VPWR sky130_fd_sc_hd__decap_3
XFILLER_27_404 VGND VGND VPWR VPWR sky130_fd_sc_hd__decap_3
XFILLER_39_275 VGND VGND VPWR VPWR sky130_fd_sc_hd__decap_3
XFILLER_54_212 VGND VGND VPWR VPWR sky130_fd_sc_hd__decap_3
XFILLER_67_573 VGND VGND VPWR VPWR sky130_fd_sc_hd__decap_3
XFILLER_54_245 VGND VGND VPWR VPWR sky130_fd_sc_hd__decap_3
XFILLER_54_256 VGND VGND VPWR VPWR sky130_fd_sc_hd__decap_3
XFILLER_54_278 VGND VGND VPWR VPWR sky130_fd_sc_hd__decap_3
XFILLER_82_565 VGND VGND VPWR VPWR sky130_fd_sc_hd__decap_3
XTAP_TAPCELL_ROW_68_1068 VGND VPWR sky130_fd_sc_hd__tapvpwrvgnd_1
X_6916_ _6936_/CLK _6916_/D VGND VGND VPWR VPWR _6916_/Q sky130_fd_sc_hd__dfxtp_2
XTAP_TAPCELL_ROW_81_1224 VGND VPWR sky130_fd_sc_hd__tapvpwrvgnd_1
XFILLER_52_27 VGND VGND VPWR VPWR sky130_fd_sc_hd__fill_1
XFILLER_52_38 VGND VGND VPWR VPWR sky130_fd_sc_hd__decap_3
X_6847_ _6978_/CLK _6847_/D VGND VGND VPWR VPWR _6847_/Q sky130_fd_sc_hd__dfxtp_2
XFILLER_10_315 VGND VGND VPWR VPWR sky130_fd_sc_hd__decap_3
XFILLER_22_153 VGND VGND VPWR VPWR sky130_fd_sc_hd__decap_3
XFILLER_52_49 VGND VGND VPWR VPWR sky130_fd_sc_hd__decap_3
X_6778_ _6936_/CLK _6778_/D VGND VGND VPWR VPWR _6778_/Q sky130_fd_sc_hd__dfxtp_2
XTAP_TAPCELL_ROW_61_980 VGND VPWR sky130_fd_sc_hd__tapvpwrvgnd_1
XFILLER_10_348 VGND VGND VPWR VPWR sky130_fd_sc_hd__decap_3
XFILLER_22_186 VGND VGND VPWR VPWR sky130_fd_sc_hd__decap_3
XFILLER_22_197 VGND VGND VPWR VPWR sky130_fd_sc_hd__decap_3
X_5729_ _7370_/Q hold925/X _5729_/S VGND VGND VPWR VPWR _6714_/D sky130_fd_sc_hd__mux2_2
XFILLER_108_214 VGND VGND VPWR VPWR sky130_fd_sc_hd__decap_3
XTAP_TAPCELL_ROW_79_1197 VGND VPWR sky130_fd_sc_hd__tapvpwrvgnd_1
XTAP_TAPCELL_ROW_92_1353 VGND VPWR sky130_fd_sc_hd__tapvpwrvgnd_1
XFILLER_104_442 VGND VGND VPWR VPWR sky130_fd_sc_hd__decap_3
XFILLER_77_24 VGND VGND VPWR VPWR sky130_fd_sc_hd__decap_3
XFILLER_77_46 VGND VGND VPWR VPWR sky130_fd_sc_hd__decap_3
XFILLER_89_142 VGND VGND VPWR VPWR sky130_fd_sc_hd__decap_3
XFILLER_77_337 VGND VGND VPWR VPWR sky130_fd_sc_hd__decap_3
XFILLER_77_57 VGND VGND VPWR VPWR sky130_fd_sc_hd__decap_3
XFILLER_85_370 VGND VGND VPWR VPWR sky130_fd_sc_hd__fill_1
XFILLER_92_318 VGND VGND VPWR VPWR sky130_fd_sc_hd__decap_3
XFILLER_93_12 VGND VGND VPWR VPWR sky130_fd_sc_hd__decap_3
Xhold1060 _7398_/Q VGND VGND VPWR VPWR _3750_/A1 sky130_fd_sc_hd__dlygate4sd3_1
XFILLER_73_532 VGND VGND VPWR VPWR sky130_fd_sc_hd__decap_3
XFILLER_93_34 VGND VGND VPWR VPWR sky130_fd_sc_hd__decap_3
Xhold1071 _7267_/Q VGND VGND VPWR VPWR _4914_/A0 sky130_fd_sc_hd__dlygate4sd3_1
Xhold1082 _7251_/Q VGND VGND VPWR VPWR _5136_/A0 sky130_fd_sc_hd__dlygate4sd3_1
Xhold1093 _7302_/Q VGND VGND VPWR VPWR _4556_/A sky130_fd_sc_hd__dlygate4sd3_1
XFILLER_45_256 VGND VGND VPWR VPWR sky130_fd_sc_hd__decap_3
XFILLER_14_610 VGND VGND VPWR VPWR sky130_fd_sc_hd__decap_3
XFILLER_26_61 VGND VGND VPWR VPWR sky130_fd_sc_hd__decap_3
XFILLER_60_226 VGND VGND VPWR VPWR sky130_fd_sc_hd__decap_3
XFILLER_13_131 VGND VGND VPWR VPWR sky130_fd_sc_hd__decap_3
XFILLER_60_259 VGND VGND VPWR VPWR sky130_fd_sc_hd__decap_3
XFILLER_13_175 VGND VGND VPWR VPWR sky130_fd_sc_hd__decap_3
XTAP_TAPCELL_ROW_31_619 VGND VPWR sky130_fd_sc_hd__tapvpwrvgnd_1
XTAP_TAPCELL_ROW_101_1460 VGND VPWR sky130_fd_sc_hd__tapvpwrvgnd_1
XFILLER_9_113 VGND VGND VPWR VPWR sky130_fd_sc_hd__decap_3
XFILLER_41_495 VGND VGND VPWR VPWR sky130_fd_sc_hd__decap_3
XFILLER_9_146 VGND VGND VPWR VPWR sky130_fd_sc_hd__decap_3
XTAP_TAPCELL_ROW_11_387 VGND VPWR sky130_fd_sc_hd__tapvpwrvgnd_1
XFILLER_5_352 VGND VGND VPWR VPWR sky130_fd_sc_hd__decap_3
XFILLER_107_291 VGND VGND VPWR VPWR sky130_fd_sc_hd__decap_3
XFILLER_47_6 VGND VGND VPWR VPWR sky130_fd_sc_hd__decap_3
XFILLER_5_385 VGND VGND VPWR VPWR sky130_fd_sc_hd__decap_3
XFILLER_3_21 VGND VGND VPWR VPWR sky130_fd_sc_hd__decap_3
XFILLER_96_613 VGND VGND VPWR VPWR sky130_fd_sc_hd__decap_3
XFILLER_110_401 VGND VGND VPWR VPWR sky130_fd_sc_hd__decap_3
XFILLER_68_315 VGND VGND VPWR VPWR sky130_fd_sc_hd__decap_3
XFILLER_95_101 VGND VGND VPWR VPWR sky130_fd_sc_hd__decap_3
XFILLER_110_445 VGND VGND VPWR VPWR sky130_fd_sc_hd__decap_3
XFILLER_68_359 VGND VGND VPWR VPWR sky130_fd_sc_hd__decap_3
XFILLER_95_145 VGND VGND VPWR VPWR sky130_fd_sc_hd__decap_3
X_4060_ _7084_/Q _4432_/A2 _4432_/B1 _4059_/X VGND VGND VPWR VPWR _4068_/A sky130_fd_sc_hd__o211a_2
XFILLER_64_510 VGND VGND VPWR VPWR sky130_fd_sc_hd__decap_3
XFILLER_67_90 VGND VGND VPWR VPWR sky130_fd_sc_hd__decap_3
XFILLER_83_318 VGND VGND VPWR VPWR sky130_fd_sc_hd__decap_3
XTAP_TAPCELL_ROW_39_719 VGND VPWR sky130_fd_sc_hd__tapvpwrvgnd_1
XFILLER_36_245 VGND VGND VPWR VPWR sky130_fd_sc_hd__decap_3
XFILLER_36_267 VGND VGND VPWR VPWR sky130_fd_sc_hd__decap_3
XFILLER_64_554 VGND VGND VPWR VPWR sky130_fd_sc_hd__decap_3
XFILLER_64_576 VGND VGND VPWR VPWR sky130_fd_sc_hd__decap_3
XFILLER_64_587 VGND VGND VPWR VPWR sky130_fd_sc_hd__fill_1
XFILLER_91_340 VGND VGND VPWR VPWR sky130_fd_sc_hd__decap_3
XFILLER_51_215 VGND VGND VPWR VPWR sky130_fd_sc_hd__decap_3
XFILLER_51_237 VGND VGND VPWR VPWR sky130_fd_sc_hd__decap_3
XFILLER_91_373 VGND VGND VPWR VPWR sky130_fd_sc_hd__decap_3
X_4962_ _6994_/Q _4977_/A VGND VGND VPWR VPWR _4963_/B sky130_fd_sc_hd__nor2_2
XTAP_TAPCELL_ROW_19_476 VGND VPWR sky130_fd_sc_hd__tapvpwrvgnd_1
XFILLER_51_259 VGND VGND VPWR VPWR sky130_fd_sc_hd__fill_1
X_6701_ _7383_/CLK _6701_/D VGND VGND VPWR VPWR _6701_/Q sky130_fd_sc_hd__dfxtp_2
X_4893_ _4928_/B _4943_/A _6996_/Q VGND VGND VPWR VPWR _4908_/B sky130_fd_sc_hd__o21a_2
X_3913_ _6857_/Q _3913_/A2 _3913_/B1 _6849_/Q _3912_/X VGND VGND VPWR VPWR _3913_/X
+ sky130_fd_sc_hd__a221o_2
X_6632_ _6632_/A VGND VGND VPWR VPWR _6632_/Y sky130_fd_sc_hd__inv_2
X_3844_ _3741_/X _3841_/X _3843_/X _3682_/A VGND VGND VPWR VPWR _3845_/B sky130_fd_sc_hd__a22o_2
X_6563_ _6599_/A VGND VGND VPWR VPWR _6563_/Y sky130_fd_sc_hd__inv_2
X_3775_ _3714_/X _3772_/X _3774_/X _3733_/X VGND VGND VPWR VPWR _3775_/X sky130_fd_sc_hd__a22o_2
X_6494_ _6651_/A VGND VGND VPWR VPWR _6494_/Y sky130_fd_sc_hd__inv_2
XFILLER_105_217 VGND VGND VPWR VPWR sky130_fd_sc_hd__decap_3
XTAP_TAPCELL_ROW_115_1629 VGND VPWR sky130_fd_sc_hd__tapvpwrvgnd_1
XFILLER_105_228 VGND VGND VPWR VPWR sky130_fd_sc_hd__decap_3
XFILLER_87_613 VGND VGND VPWR VPWR sky130_fd_sc_hd__decap_3
X_7115_ _7371_/CLK _7115_/D _6395_/Y VGND VGND VPWR VPWR _7115_/Q sky130_fd_sc_hd__dfrtp_2
Xoutput487 _3991_/B VGND VGND VPWR VPWR alu_result_out[2] sky130_fd_sc_hd__clkdlybuf4s25_1
Xoutput476 _5659_/B VGND VGND VPWR VPWR alu_result_out[1] sky130_fd_sc_hd__clkdlybuf4s25_1
Xoutput465 _5650_/Y VGND VGND VPWR VPWR alu_result_out[0] sky130_fd_sc_hd__clkdlybuf4s25_1
XFILLER_86_112 VGND VGND VPWR VPWR sky130_fd_sc_hd__decap_3
XFILLER_87_646 VGND VGND VPWR VPWR sky130_fd_sc_hd__fill_1
Xoutput498 _5647_/Y VGND VGND VPWR VPWR instruction_out[11] sky130_fd_sc_hd__clkdlybuf4s25_1
X_4327_ _4327_/A _4327_/B VGND VGND VPWR VPWR _4362_/C sky130_fd_sc_hd__nand2_2
XFILLER_99_473 VGND VGND VPWR VPWR sky130_fd_sc_hd__decap_3
XFILLER_47_27 VGND VGND VPWR VPWR sky130_fd_sc_hd__decap_3
XFILLER_87_668 VGND VGND VPWR VPWR sky130_fd_sc_hd__decap_3
X_7046_ _7393_/CLK _7046_/D _6326_/Y VGND VGND VPWR VPWR _7046_/Q sky130_fd_sc_hd__dfrtp_2
X_4258_ _4988_/A _4988_/B VGND VGND VPWR VPWR _5003_/A sky130_fd_sc_hd__or2_4
XFILLER_74_318 VGND VGND VPWR VPWR sky130_fd_sc_hd__decap_3
XFILLER_86_189 VGND VGND VPWR VPWR sky130_fd_sc_hd__decap_3
XFILLER_27_212 VGND VGND VPWR VPWR sky130_fd_sc_hd__decap_3
X_4189_ _7231_/Q _4349_/B1 _3366_/X _7167_/Q _4188_/X VGND VGND VPWR VPWR _4189_/X
+ sky130_fd_sc_hd__a221o_2
XFILLER_70_502 VGND VGND VPWR VPWR sky130_fd_sc_hd__decap_3
XFILLER_82_340 VGND VGND VPWR VPWR sky130_fd_sc_hd__decap_3
XFILLER_103_88 VGND VGND VPWR VPWR sky130_fd_sc_hd__decap_3
XFILLER_15_429 VGND VGND VPWR VPWR sky130_fd_sc_hd__decap_3
XFILLER_27_278 VGND VGND VPWR VPWR sky130_fd_sc_hd__fill_2
XFILLER_42_215 VGND VGND VPWR VPWR sky130_fd_sc_hd__fill_1
XFILLER_42_237 VGND VGND VPWR VPWR sky130_fd_sc_hd__fill_1
XFILLER_63_37 VGND VGND VPWR VPWR sky130_fd_sc_hd__decap_3
XFILLER_82_373 VGND VGND VPWR VPWR sky130_fd_sc_hd__decap_3
XFILLER_7_606 VGND VGND VPWR VPWR sky130_fd_sc_hd__fill_2
XFILLER_109_523 VGND VGND VPWR VPWR sky130_fd_sc_hd__decap_3
XFILLER_109_567 VGND VGND VPWR VPWR sky130_fd_sc_hd__fill_1
XFILLER_10_178 VGND VGND VPWR VPWR sky130_fd_sc_hd__decap_3
XFILLER_10_189 VGND VGND VPWR VPWR sky130_fd_sc_hd__decap_3
XFILLER_12_41 VGND VGND VPWR VPWR sky130_fd_sc_hd__decap_3
XFILLER_12_85 VGND VGND VPWR VPWR sky130_fd_sc_hd__decap_3
XFILLER_88_45 VGND VGND VPWR VPWR sky130_fd_sc_hd__decap_3
XFILLER_2_333 VGND VGND VPWR VPWR sky130_fd_sc_hd__decap_3
XFILLER_88_56 VGND VGND VPWR VPWR sky130_fd_sc_hd__fill_1
XFILLER_77_101 VGND VGND VPWR VPWR sky130_fd_sc_hd__decap_3
XFILLER_78_613 VGND VGND VPWR VPWR sky130_fd_sc_hd__decap_3
XFILLER_77_123 VGND VGND VPWR VPWR sky130_fd_sc_hd__decap_3
XFILLER_65_307 VGND VGND VPWR VPWR sky130_fd_sc_hd__decap_3
XFILLER_77_189 VGND VGND VPWR VPWR sky130_fd_sc_hd__decap_3
XFILLER_92_115 VGND VGND VPWR VPWR sky130_fd_sc_hd__decap_3
XFILLER_37_60 VGND VGND VPWR VPWR sky130_fd_sc_hd__decap_3
XFILLER_86_690 VGND VGND VPWR VPWR sky130_fd_sc_hd__fill_2
XFILLER_93_649 VGND VGND VPWR VPWR sky130_fd_sc_hd__fill_2
XFILLER_18_256 VGND VGND VPWR VPWR sky130_fd_sc_hd__decap_3
XFILLER_61_502 VGND VGND VPWR VPWR sky130_fd_sc_hd__fill_2
XFILLER_73_340 VGND VGND VPWR VPWR sky130_fd_sc_hd__decap_3
XPHY_EDGE_ROW_16_Right_16 VGND VGND VPWR VPWR sky130_fd_sc_hd__decap_3
XFILLER_18_289 VGND VGND VPWR VPWR sky130_fd_sc_hd__decap_3
XFILLER_61_535 VGND VGND VPWR VPWR sky130_fd_sc_hd__fill_2
XFILLER_61_546 VGND VGND VPWR VPWR sky130_fd_sc_hd__fill_1
XTAP_TAPCELL_ROW_16_446 VGND VPWR sky130_fd_sc_hd__tapvpwrvgnd_1
XFILLER_53_81 VGND VGND VPWR VPWR sky130_fd_sc_hd__decap_3
XTAP_TAPCELL_ROW_44_777 VGND VPWR sky130_fd_sc_hd__tapvpwrvgnd_1
XFILLER_41_281 VGND VGND VPWR VPWR sky130_fd_sc_hd__decap_3
X_3560_ _5118_/D _3560_/B VGND VGND VPWR VPWR _3560_/Y sky130_fd_sc_hd__nor2_2
XPHY_EDGE_ROW_25_Right_25 VGND VGND VPWR VPWR sky130_fd_sc_hd__decap_3
XFILLER_6_672 VGND VGND VPWR VPWR sky130_fd_sc_hd__decap_3
X_3491_ _7215_/Q _4262_/A2 _4348_/A2 _7151_/Q _3490_/X VGND VGND VPWR VPWR _3491_/X
+ sky130_fd_sc_hd__a221o_2
XFILLER_5_193 VGND VGND VPWR VPWR sky130_fd_sc_hd__decap_3
XFILLER_96_421 VGND VGND VPWR VPWR sky130_fd_sc_hd__decap_3
X_5161_ _5161_/A _5641_/A VGND VGND VPWR VPWR _5217_/B sky130_fd_sc_hd__or2_2
XFILLER_69_668 VGND VGND VPWR VPWR sky130_fd_sc_hd__decap_3
X_5092_ _5069_/B _5092_/B _5092_/C VGND VGND VPWR VPWR _5092_/X sky130_fd_sc_hd__and3b_2
X_4112_ _7332_/Q _3956_/S _3383_/Y _7300_/Q VGND VGND VPWR VPWR _4112_/X sky130_fd_sc_hd__a22o_2
XFILLER_56_307 VGND VGND VPWR VPWR sky130_fd_sc_hd__fill_1
XFILLER_56_318 VGND VGND VPWR VPWR sky130_fd_sc_hd__decap_3
XFILLER_83_104 VGND VGND VPWR VPWR sky130_fd_sc_hd__decap_3
XFILLER_96_465 VGND VGND VPWR VPWR sky130_fd_sc_hd__decap_3
XFILLER_96_498 VGND VGND VPWR VPWR sky130_fd_sc_hd__decap_3
X_4043_ _7309_/Q _4491_/S _4430_/B1 _7181_/Q _4042_/X VGND VGND VPWR VPWR _4043_/X
+ sky130_fd_sc_hd__a221o_2
XFILLER_110_286 VGND VGND VPWR VPWR sky130_fd_sc_hd__decap_3
XFILLER_49_370 VGND VGND VPWR VPWR sky130_fd_sc_hd__decap_3
XPHY_EDGE_ROW_34_Right_34 VGND VGND VPWR VPWR sky130_fd_sc_hd__decap_3
XFILLER_83_159 VGND VGND VPWR VPWR sky130_fd_sc_hd__decap_3
XFILLER_24_215 VGND VGND VPWR VPWR sky130_fd_sc_hd__decap_3
XTAP_TAPCELL_ROW_65_1027 VGND VPWR sky130_fd_sc_hd__tapvpwrvgnd_1
XFILLER_91_192 VGND VGND VPWR VPWR sky130_fd_sc_hd__decap_3
X_4945_ _4836_/S _6995_/D _5657_/C _4944_/X VGND VGND VPWR VPWR _4945_/X sky130_fd_sc_hd__o22a_2
XFILLER_33_18 VGND VGND VPWR VPWR sky130_fd_sc_hd__fill_1
XFILLER_52_579 VGND VGND VPWR VPWR sky130_fd_sc_hd__fill_1
XFILLER_20_421 VGND VGND VPWR VPWR sky130_fd_sc_hd__decap_3
XFILLER_32_270 VGND VGND VPWR VPWR sky130_fd_sc_hd__decap_3
XFILLER_32_292 VGND VGND VPWR VPWR sky130_fd_sc_hd__decap_3
X_6615_ _6619_/A VGND VGND VPWR VPWR _6615_/Y sky130_fd_sc_hd__inv_2
X_3827_ _6700_/Q _3925_/A2 _3827_/B1 _6878_/Q VGND VGND VPWR VPWR _3827_/X sky130_fd_sc_hd__a22o_2
XPHY_EDGE_ROW_43_Right_43 VGND VGND VPWR VPWR sky130_fd_sc_hd__decap_3
X_6546_ _6578_/A VGND VGND VPWR VPWR _6546_/Y sky130_fd_sc_hd__inv_2
XFILLER_106_526 VGND VGND VPWR VPWR sky130_fd_sc_hd__decap_3
XFILLER_3_119 VGND VGND VPWR VPWR sky130_fd_sc_hd__decap_3
X_6477_ _6608_/A VGND VGND VPWR VPWR _6477_/Y sky130_fd_sc_hd__inv_2
XTAP_TAPCELL_ROW_76_1167 VGND VPWR sky130_fd_sc_hd__tapvpwrvgnd_1
XFILLER_114_570 VGND VGND VPWR VPWR sky130_fd_sc_hd__fill_2
XFILLER_114_581 VGND VGND VPWR VPWR sky130_fd_sc_hd__decap_3
XFILLER_58_15 VGND VGND VPWR VPWR sky130_fd_sc_hd__decap_3
XFILLER_99_281 VGND VGND VPWR VPWR sky130_fd_sc_hd__decap_3
XFILLER_99_270 VGND VGND VPWR VPWR sky130_fd_sc_hd__decap_3
XFILLER_59_134 VGND VGND VPWR VPWR sky130_fd_sc_hd__decap_3
XFILLER_87_443 VGND VGND VPWR VPWR sky130_fd_sc_hd__decap_3
XFILLER_114_43 VGND VGND VPWR VPWR sky130_fd_sc_hd__decap_3
XFILLER_47_329 VGND VGND VPWR VPWR sky130_fd_sc_hd__decap_3
XFILLER_59_156 VGND VGND VPWR VPWR sky130_fd_sc_hd__decap_3
XFILLER_75_638 VGND VGND VPWR VPWR sky130_fd_sc_hd__decap_3
XFILLER_87_476 VGND VGND VPWR VPWR sky130_fd_sc_hd__decap_3
X_7029_ _7381_/CLK _7029_/D _6309_/Y VGND VGND VPWR VPWR _7029_/Q sky130_fd_sc_hd__dfrtp_2
XPHY_EDGE_ROW_52_Right_52 VGND VGND VPWR VPWR sky130_fd_sc_hd__decap_3
XFILLER_114_65 VGND VGND VPWR VPWR sky130_fd_sc_hd__decap_3
XFILLER_28_510 VGND VGND VPWR VPWR sky130_fd_sc_hd__fill_2
XFILLER_74_115 VGND VGND VPWR VPWR sky130_fd_sc_hd__decap_3
XFILLER_74_137 VGND VGND VPWR VPWR sky130_fd_sc_hd__decap_3
XFILLER_74_159 VGND VGND VPWR VPWR sky130_fd_sc_hd__decap_3
XFILLER_55_373 VGND VGND VPWR VPWR sky130_fd_sc_hd__decap_3
XFILLER_74_69 VGND VGND VPWR VPWR sky130_fd_sc_hd__decap_3
XFILLER_83_671 VGND VGND VPWR VPWR sky130_fd_sc_hd__fill_1
XFILLER_83_682 VGND VGND VPWR VPWR sky130_fd_sc_hd__fill_2
XTAP_TAPCELL_ROW_87_1296 VGND VPWR sky130_fd_sc_hd__tapvpwrvgnd_1
XFILLER_15_237 VGND VGND VPWR VPWR sky130_fd_sc_hd__decap_3
XFILLER_70_332 VGND VGND VPWR VPWR sky130_fd_sc_hd__decap_3
XFILLER_82_192 VGND VGND VPWR VPWR sky130_fd_sc_hd__fill_1
XFILLER_43_579 VGND VGND VPWR VPWR sky130_fd_sc_hd__decap_3
XFILLER_70_365 VGND VGND VPWR VPWR sky130_fd_sc_hd__decap_3
XFILLER_90_35 VGND VGND VPWR VPWR sky130_fd_sc_hd__decap_3
XTAP_TAPCELL_ROW_13_405 VGND VPWR sky130_fd_sc_hd__tapvpwrvgnd_1
XFILLER_23_281 VGND VGND VPWR VPWR sky130_fd_sc_hd__decap_3
XFILLER_90_68 VGND VGND VPWR VPWR sky130_fd_sc_hd__decap_3
XTAP_TAPCELL_ROW_41_747 VGND VPWR sky130_fd_sc_hd__tapvpwrvgnd_1
XPHY_EDGE_ROW_61_Right_61 VGND VGND VPWR VPWR sky130_fd_sc_hd__decap_3
XFILLER_109_331 VGND VGND VPWR VPWR sky130_fd_sc_hd__decap_3
XFILLER_23_84 VGND VGND VPWR VPWR sky130_fd_sc_hd__fill_2
XFILLER_7_458 VGND VGND VPWR VPWR sky130_fd_sc_hd__decap_3
XFILLER_99_22 VGND VGND VPWR VPWR sky130_fd_sc_hd__decap_3
XFILLER_109_364 VGND VGND VPWR VPWR sky130_fd_sc_hd__decap_3
XFILLER_99_55 VGND VGND VPWR VPWR sky130_fd_sc_hd__fill_1
XFILLER_99_66 VGND VGND VPWR VPWR sky130_fd_sc_hd__decap_3
XFILLER_112_507 VGND VGND VPWR VPWR sky130_fd_sc_hd__decap_3
XFILLER_99_99 VGND VGND VPWR VPWR sky130_fd_sc_hd__decap_3
XFILLER_2_141 VGND VGND VPWR VPWR sky130_fd_sc_hd__decap_3
XPHY_EDGE_ROW_70_Right_70 VGND VGND VPWR VPWR sky130_fd_sc_hd__decap_3
XFILLER_78_443 VGND VGND VPWR VPWR sky130_fd_sc_hd__decap_3
XFILLER_38_318 VGND VGND VPWR VPWR sky130_fd_sc_hd__fill_2
XFILLER_48_70 VGND VGND VPWR VPWR sky130_fd_sc_hd__decap_3
XFILLER_65_104 VGND VGND VPWR VPWR sky130_fd_sc_hd__decap_3
XFILLER_93_402 VGND VGND VPWR VPWR sky130_fd_sc_hd__decap_3
XFILLER_19_532 VGND VGND VPWR VPWR sky130_fd_sc_hd__decap_3
XFILLER_66_638 VGND VGND VPWR VPWR sky130_fd_sc_hd__decap_3
XTAP_TAPCELL_ROW_49_836 VGND VPWR sky130_fd_sc_hd__tapvpwrvgnd_1
XFILLER_46_351 VGND VGND VPWR VPWR sky130_fd_sc_hd__decap_3
XFILLER_65_159 VGND VGND VPWR VPWR sky130_fd_sc_hd__decap_3
XFILLER_93_468 VGND VGND VPWR VPWR sky130_fd_sc_hd__fill_1
XFILLER_34_502 VGND VGND VPWR VPWR sky130_fd_sc_hd__decap_3
XFILLER_80_107 VGND VGND VPWR VPWR sky130_fd_sc_hd__decap_3
XFILLER_46_395 VGND VGND VPWR VPWR sky130_fd_sc_hd__decap_3
XFILLER_61_321 VGND VGND VPWR VPWR sky130_fd_sc_hd__decap_3
XFILLER_73_181 VGND VGND VPWR VPWR sky130_fd_sc_hd__decap_3
XPHY_EDGE_ROW_14_Left_131 VGND VGND VPWR VPWR sky130_fd_sc_hd__decap_3
X_4730_ _7007_/Q _4738_/A VGND VGND VPWR VPWR _4731_/A sky130_fd_sc_hd__or2_2
XFILLER_9_53 VGND VGND VPWR VPWR sky130_fd_sc_hd__decap_3
XFILLER_9_31 VGND VGND VPWR VPWR sky130_fd_sc_hd__decap_3
X_7380_ clkload3/A _7380_/D _6660_/Y VGND VGND VPWR VPWR _7380_/Q sky130_fd_sc_hd__dfrtp_2
X_6400_ _6637_/A VGND VGND VPWR VPWR _6400_/Y sky130_fd_sc_hd__inv_2
X_3612_ _3536_/B _4614_/B _3610_/Y _3611_/Y VGND VGND VPWR VPWR _3612_/X sky130_fd_sc_hd__a211o_2
Xhold904 _7100_/Q VGND VGND VPWR VPWR _7100_/D sky130_fd_sc_hd__dlygate4sd3_1
X_6331_ _6682_/A VGND VGND VPWR VPWR _6331_/Y sky130_fd_sc_hd__inv_2
XFILLER_115_323 VGND VGND VPWR VPWR sky130_fd_sc_hd__decap_3
Xhold915 _6713_/Q VGND VGND VPWR VPWR hold915/X sky130_fd_sc_hd__dlygate4sd3_1
Xhold926 _6717_/Q VGND VGND VPWR VPWR hold926/X sky130_fd_sc_hd__dlygate4sd3_1
Xhold937 _5686_/X VGND VGND VPWR VPWR _6693_/D sky130_fd_sc_hd__dlygate4sd3_1
X_3543_ _3540_/X _3541_/X _5144_/A VGND VGND VPWR VPWR _3630_/B sky130_fd_sc_hd__o21ai_2
XFILLER_115_356 VGND VGND VPWR VPWR sky130_fd_sc_hd__decap_3
Xhold959 _7016_/Q VGND VGND VPWR VPWR _5624_/A sky130_fd_sc_hd__dlygate4sd3_1
Xhold948 _6716_/Q VGND VGND VPWR VPWR hold948/X sky130_fd_sc_hd__dlygate4sd3_1
X_6262_ _6642_/A VGND VGND VPWR VPWR _6262_/Y sky130_fd_sc_hd__inv_2
X_3474_ _7280_/Q _4522_/S _4339_/B1 _7152_/Q _3473_/X VGND VGND VPWR VPWR _3474_/X
+ sky130_fd_sc_hd__a221o_2
XPHY_EDGE_ROW_23_Left_140 VGND VGND VPWR VPWR sky130_fd_sc_hd__decap_3
XFILLER_88_229 VGND VGND VPWR VPWR sky130_fd_sc_hd__decap_3
X_5213_ _7222_/Q _5225_/B VGND VGND VPWR VPWR _7222_/D sky130_fd_sc_hd__and2_2
XFILLER_69_432 VGND VGND VPWR VPWR sky130_fd_sc_hd__decap_3
X_5144_ _5144_/A _5144_/B VGND VGND VPWR VPWR _5145_/A sky130_fd_sc_hd__nand2_2
XFILLER_28_18 VGND VGND VPWR VPWR sky130_fd_sc_hd__decap_3
XFILLER_28_29 VGND VGND VPWR VPWR sky130_fd_sc_hd__decap_3
XFILLER_29_307 VGND VGND VPWR VPWR sky130_fd_sc_hd__decap_3
XFILLER_96_240 VGND VGND VPWR VPWR sky130_fd_sc_hd__decap_3
XFILLER_96_262 VGND VGND VPWR VPWR sky130_fd_sc_hd__decap_3
XFILLER_29_329 VGND VGND VPWR VPWR sky130_fd_sc_hd__decap_3
XFILLER_56_137 VGND VGND VPWR VPWR sky130_fd_sc_hd__decap_3
XFILLER_84_424 VGND VGND VPWR VPWR sky130_fd_sc_hd__decap_3
XFILLER_96_295 VGND VGND VPWR VPWR sky130_fd_sc_hd__decap_3
X_5075_ _5075_/A _5075_/B _5075_/C VGND VGND VPWR VPWR _5658_/A sky130_fd_sc_hd__or3_2
XFILLER_56_159 VGND VGND VPWR VPWR sky130_fd_sc_hd__decap_3
XFILLER_84_468 VGND VGND VPWR VPWR sky130_fd_sc_hd__decap_3
XFILLER_25_502 VGND VGND VPWR VPWR sky130_fd_sc_hd__fill_2
XFILLER_37_373 VGND VGND VPWR VPWR sky130_fd_sc_hd__decap_3
XFILLER_71_129 VGND VGND VPWR VPWR sky130_fd_sc_hd__fill_1
XFILLER_25_535 VGND VGND VPWR VPWR sky130_fd_sc_hd__decap_3
XFILLER_52_321 VGND VGND VPWR VPWR sky130_fd_sc_hd__decap_3
XFILLER_80_641 VGND VGND VPWR VPWR sky130_fd_sc_hd__decap_3
XFILLER_12_218 VGND VGND VPWR VPWR sky130_fd_sc_hd__decap_3
XFILLER_52_354 VGND VGND VPWR VPWR sky130_fd_sc_hd__decap_3
XFILLER_52_365 VGND VGND VPWR VPWR sky130_fd_sc_hd__decap_3
XFILLER_100_23 VGND VGND VPWR VPWR sky130_fd_sc_hd__decap_3
X_4928_ _6996_/Q _4928_/B _4943_/A VGND VGND VPWR VPWR _4928_/Y sky130_fd_sc_hd__nor3_2
XFILLER_100_67 VGND VGND VPWR VPWR sky130_fd_sc_hd__decap_3
XFILLER_60_27 VGND VGND VPWR VPWR sky130_fd_sc_hd__fill_1
XFILLER_20_262 VGND VGND VPWR VPWR sky130_fd_sc_hd__fill_1
XFILLER_60_49 VGND VGND VPWR VPWR sky130_fd_sc_hd__decap_3
X_4859_ _7000_/Q _4870_/A VGND VGND VPWR VPWR _4859_/Y sky130_fd_sc_hd__nor2_2
XFILLER_20_295 VGND VGND VPWR VPWR sky130_fd_sc_hd__decap_3
Xclkbuf_3_0__f_clk clkbuf_0_clk/X VGND VGND VPWR VPWR clkbuf_3_0__f_clk/X sky130_fd_sc_hd__clkbuf_16
XFILLER_106_312 VGND VGND VPWR VPWR sky130_fd_sc_hd__decap_3
XFILLER_109_43 VGND VGND VPWR VPWR sky130_fd_sc_hd__decap_3
XFILLER_4_417 VGND VGND VPWR VPWR sky130_fd_sc_hd__decap_3
X_6529_ _6562_/A VGND VGND VPWR VPWR _6529_/Y sky130_fd_sc_hd__inv_2
XFILLER_106_345 VGND VGND VPWR VPWR sky130_fd_sc_hd__decap_3
XFILLER_69_69 VGND VGND VPWR VPWR sky130_fd_sc_hd__fill_1
XFILLER_79_207 VGND VGND VPWR VPWR sky130_fd_sc_hd__decap_3
XFILLER_47_104 VGND VGND VPWR VPWR sky130_fd_sc_hd__decap_3
XFILLER_75_402 VGND VGND VPWR VPWR sky130_fd_sc_hd__decap_3
XFILLER_102_595 VGND VGND VPWR VPWR sky130_fd_sc_hd__decap_3
XFILLER_47_126 VGND VGND VPWR VPWR sky130_fd_sc_hd__decap_3
XFILLER_85_57 VGND VGND VPWR VPWR sky130_fd_sc_hd__decap_3
XFILLER_87_284 VGND VGND VPWR VPWR sky130_fd_sc_hd__decap_3
XTAP_TAPCELL_ROW_89_1325 VGND VPWR sky130_fd_sc_hd__tapvpwrvgnd_1
XTAP_TAPCELL_ROW_89_1314 VGND VPWR sky130_fd_sc_hd__tapvpwrvgnd_1
XFILLER_75_479 VGND VGND VPWR VPWR sky130_fd_sc_hd__decap_3
XFILLER_90_405 VGND VGND VPWR VPWR sky130_fd_sc_hd__fill_1
XTAP_TAPCELL_ROW_46_806 VGND VPWR sky130_fd_sc_hd__tapvpwrvgnd_1
XFILLER_28_362 VGND VGND VPWR VPWR sky130_fd_sc_hd__fill_2
XFILLER_28_384 VGND VGND VPWR VPWR sky130_fd_sc_hd__fill_1
XFILLER_16_546 VGND VGND VPWR VPWR sky130_fd_sc_hd__decap_3
XFILLER_43_321 VGND VGND VPWR VPWR sky130_fd_sc_hd__decap_3
XFILLER_43_343 VGND VGND VPWR VPWR sky130_fd_sc_hd__decap_3
XFILLER_55_192 VGND VGND VPWR VPWR sky130_fd_sc_hd__decap_3
XFILLER_71_641 VGND VGND VPWR VPWR sky130_fd_sc_hd__decap_3
XFILLER_31_505 VGND VGND VPWR VPWR sky130_fd_sc_hd__decap_3
XFILLER_71_685 VGND VGND VPWR VPWR sky130_fd_sc_hd__fill_1
XTAP_TAPCELL_ROW_26_563 VGND VPWR sky130_fd_sc_hd__tapvpwrvgnd_1
XTAP_TAPCELL_ROW_54_894 VGND VPWR sky130_fd_sc_hd__tapvpwrvgnd_1
XFILLER_11_240 VGND VGND VPWR VPWR sky130_fd_sc_hd__decap_3
XFILLER_11_273 VGND VGND VPWR VPWR sky130_fd_sc_hd__decap_3
XFILLER_11_284 VGND VGND VPWR VPWR sky130_fd_sc_hd__decap_3
XFILLER_7_211 VGND VGND VPWR VPWR sky130_fd_sc_hd__decap_3
XFILLER_7_244 VGND VGND VPWR VPWR sky130_fd_sc_hd__decap_3
XFILLER_50_82 VGND VGND VPWR VPWR sky130_fd_sc_hd__fill_2
XFILLER_7_277 VGND VGND VPWR VPWR sky130_fd_sc_hd__decap_3
XFILLER_7_299 VGND VGND VPWR VPWR sky130_fd_sc_hd__decap_3
XFILLER_109_194 VGND VGND VPWR VPWR sky130_fd_sc_hd__decap_3
XFILLER_112_326 VGND VGND VPWR VPWR sky130_fd_sc_hd__decap_3
XFILLER_98_516 VGND VGND VPWR VPWR sky130_fd_sc_hd__decap_3
XFILLER_112_359 VGND VGND VPWR VPWR sky130_fd_sc_hd__decap_3
XFILLER_59_80 VGND VGND VPWR VPWR sky130_fd_sc_hd__fill_2
XFILLER_66_402 VGND VGND VPWR VPWR sky130_fd_sc_hd__fill_2
XFILLER_78_251 VGND VGND VPWR VPWR sky130_fd_sc_hd__fill_1
XFILLER_38_115 VGND VGND VPWR VPWR sky130_fd_sc_hd__decap_3
XFILLER_66_413 VGND VGND VPWR VPWR sky130_fd_sc_hd__decap_3
XFILLER_66_424 VGND VGND VPWR VPWR sky130_fd_sc_hd__decap_3
XFILLER_19_340 VGND VGND VPWR VPWR sky130_fd_sc_hd__decap_3
XFILLER_38_159 VGND VGND VPWR VPWR sky130_fd_sc_hd__decap_3
XFILLER_81_405 VGND VGND VPWR VPWR sky130_fd_sc_hd__decap_3
XFILLER_93_243 VGND VGND VPWR VPWR sky130_fd_sc_hd__decap_3
XFILLER_93_265 VGND VGND VPWR VPWR sky130_fd_sc_hd__decap_3
XFILLER_19_384 VGND VGND VPWR VPWR sky130_fd_sc_hd__decap_3
XTAP_TAPCELL_ROW_109_1561 VGND VPWR sky130_fd_sc_hd__tapvpwrvgnd_1
XFILLER_46_170 VGND VGND VPWR VPWR sky130_fd_sc_hd__decap_3
XFILLER_74_490 VGND VGND VPWR VPWR sky130_fd_sc_hd__decap_3
XFILLER_81_449 VGND VGND VPWR VPWR sky130_fd_sc_hd__decap_3
X_6880_ _7198_/CLK _6880_/D VGND VGND VPWR VPWR _6880_/Q sky130_fd_sc_hd__dfxtp_2
XFILLER_34_354 VGND VGND VPWR VPWR sky130_fd_sc_hd__decap_3
XFILLER_34_365 VGND VGND VPWR VPWR sky130_fd_sc_hd__decap_3
XFILLER_61_140 VGND VGND VPWR VPWR sky130_fd_sc_hd__decap_3
XFILLER_34_398 VGND VGND VPWR VPWR sky130_fd_sc_hd__fill_2
XFILLER_61_184 VGND VGND VPWR VPWR sky130_fd_sc_hd__decap_3
X_4713_ _7008_/Q _4731_/B VGND VGND VPWR VPWR _7008_/D sky130_fd_sc_hd__xnor2_2
X_5693_ _7352_/Q hold923/X _5708_/S VGND VGND VPWR VPWR _6696_/D sky130_fd_sc_hd__mux2_2
X_4644_ _4111_/B _4643_/Y _4633_/A _4109_/X VGND VGND VPWR VPWR _4644_/X sky130_fd_sc_hd__a211o_2
X_7363_ _7363_/CLK _7363_/D _6643_/Y VGND VGND VPWR VPWR _7363_/Q sky130_fd_sc_hd__dfrtp_2
Xhold701 _6842_/Q VGND VGND VPWR VPWR _6842_/D sky130_fd_sc_hd__dlygate4sd3_1
Xhold712 _6743_/Q VGND VGND VPWR VPWR _6743_/D sky130_fd_sc_hd__dlygate4sd3_1
X_4575_ _4575_/A _4583_/B VGND VGND VPWR VPWR _7293_/D sky130_fd_sc_hd__and2_2
XFILLER_89_505 VGND VGND VPWR VPWR sky130_fd_sc_hd__decap_3
X_7294_ _7294_/CLK _7294_/D _6574_/Y VGND VGND VPWR VPWR _7294_/Q sky130_fd_sc_hd__dfrtp_2
Xhold723 _6883_/Q VGND VGND VPWR VPWR _6883_/D sky130_fd_sc_hd__dlygate4sd3_1
Xhold734 _6876_/Q VGND VGND VPWR VPWR _6876_/D sky130_fd_sc_hd__dlygate4sd3_1
Xhold745 _6810_/Q VGND VGND VPWR VPWR _6810_/D sky130_fd_sc_hd__dlygate4sd3_1
X_6314_ _6634_/A VGND VGND VPWR VPWR _6314_/Y sky130_fd_sc_hd__inv_2
X_3526_ _4938_/A _3604_/B VGND VGND VPWR VPWR _5057_/A sky130_fd_sc_hd__nand2_2
XFILLER_115_175 VGND VGND VPWR VPWR sky130_fd_sc_hd__decap_3
XFILLER_116_676 VGND VGND VPWR VPWR sky130_fd_sc_hd__decap_3
Xhold756 _6846_/Q VGND VGND VPWR VPWR _6846_/D sky130_fd_sc_hd__dlygate4sd3_1
Xhold767 _6778_/Q VGND VGND VPWR VPWR _6778_/D sky130_fd_sc_hd__dlygate4sd3_1
Xhold778 _6871_/Q VGND VGND VPWR VPWR _6871_/D sky130_fd_sc_hd__dlygate4sd3_1
XTAP_TAPCELL_ROW_73_1126 VGND VPWR sky130_fd_sc_hd__tapvpwrvgnd_1
XFILLER_103_326 VGND VGND VPWR VPWR sky130_fd_sc_hd__decap_3
XFILLER_103_337 VGND VGND VPWR VPWR sky130_fd_sc_hd__decap_3
XFILLER_39_39 VGND VGND VPWR VPWR sky130_fd_sc_hd__fill_1
XFILLER_89_549 VGND VGND VPWR VPWR sky130_fd_sc_hd__decap_3
Xhold789 _6850_/Q VGND VGND VPWR VPWR _6850_/D sky130_fd_sc_hd__dlygate4sd3_1
X_3457_ _4394_/A _3449_/C _3424_/S _3456_/X VGND VGND VPWR VPWR _3506_/B sky130_fd_sc_hd__a22o_2
XFILLER_57_402 VGND VGND VPWR VPWR sky130_fd_sc_hd__decap_3
XFILLER_69_240 VGND VGND VPWR VPWR sky130_fd_sc_hd__decap_3
X_3388_ _3394_/A _3429_/B VGND VGND VPWR VPWR _3556_/A sky130_fd_sc_hd__nor2_2
XFILLER_69_273 VGND VGND VPWR VPWR sky130_fd_sc_hd__decap_3
XFILLER_69_284 VGND VGND VPWR VPWR sky130_fd_sc_hd__decap_3
XFILLER_55_16 VGND VGND VPWR VPWR sky130_fd_sc_hd__decap_3
XFILLER_84_243 VGND VGND VPWR VPWR sky130_fd_sc_hd__decap_3
X_5058_ _5114_/A _4330_/B _5056_/X _5057_/Y VGND VGND VPWR VPWR _5662_/B sky130_fd_sc_hd__a211o_2
XPHY_EDGE_ROW_2_Right_2 VGND VGND VPWR VPWR sky130_fd_sc_hd__decap_3
XFILLER_44_107 VGND VGND VPWR VPWR sky130_fd_sc_hd__decap_3
XFILLER_72_416 VGND VGND VPWR VPWR sky130_fd_sc_hd__decap_3
XFILLER_72_427 VGND VGND VPWR VPWR sky130_fd_sc_hd__decap_3
XFILLER_84_276 VGND VGND VPWR VPWR sky130_fd_sc_hd__decap_3
XFILLER_111_22 VGND VGND VPWR VPWR sky130_fd_sc_hd__decap_3
XFILLER_25_332 VGND VGND VPWR VPWR sky130_fd_sc_hd__decap_3
XFILLER_25_343 VGND VGND VPWR VPWR sky130_fd_sc_hd__decap_3
XFILLER_37_181 VGND VGND VPWR VPWR sky130_fd_sc_hd__decap_3
XFILLER_111_55 VGND VGND VPWR VPWR sky130_fd_sc_hd__fill_1
XFILLER_25_376 VGND VGND VPWR VPWR sky130_fd_sc_hd__decap_3
XFILLER_52_162 VGND VGND VPWR VPWR sky130_fd_sc_hd__decap_3
XTAP_TAPCELL_ROW_84_1255 VGND VPWR sky130_fd_sc_hd__tapvpwrvgnd_1
XFILLER_40_324 VGND VGND VPWR VPWR sky130_fd_sc_hd__decap_3
XFILLER_52_195 VGND VGND VPWR VPWR sky130_fd_sc_hd__fill_1
XTAP_TAPCELL_ROW_23_522 VGND VPWR sky130_fd_sc_hd__tapvpwrvgnd_1
XFILLER_40_357 VGND VGND VPWR VPWR sky130_fd_sc_hd__decap_3
XFILLER_40_368 VGND VGND VPWR VPWR sky130_fd_sc_hd__decap_3
XTAP_TAPCELL_ROW_51_864 VGND VPWR sky130_fd_sc_hd__tapvpwrvgnd_1
XTAP_TAPCELL_ROW_23_533 VGND VPWR sky130_fd_sc_hd__tapvpwrvgnd_1
XFILLER_4_203 VGND VGND VPWR VPWR sky130_fd_sc_hd__decap_3
XFILLER_20_41 VGND VGND VPWR VPWR sky130_fd_sc_hd__decap_3
XFILLER_20_85 VGND VGND VPWR VPWR sky130_fd_sc_hd__decap_3
XTAP_TAPCELL_ROW_95_1395 VGND VPWR sky130_fd_sc_hd__tapvpwrvgnd_1
XFILLER_106_186 VGND VGND VPWR VPWR sky130_fd_sc_hd__decap_3
XFILLER_106_197 VGND VGND VPWR VPWR sky130_fd_sc_hd__decap_3
XFILLER_96_23 VGND VGND VPWR VPWR sky130_fd_sc_hd__decap_3
XFILLER_88_571 VGND VGND VPWR VPWR sky130_fd_sc_hd__fill_1
XFILLER_95_508 VGND VGND VPWR VPWR sky130_fd_sc_hd__decap_3
XFILLER_102_381 VGND VGND VPWR VPWR sky130_fd_sc_hd__decap_3
XFILLER_29_50 VGND VGND VPWR VPWR sky130_fd_sc_hd__decap_3
XFILLER_48_424 VGND VGND VPWR VPWR sky130_fd_sc_hd__decap_3
XFILLER_75_210 VGND VGND VPWR VPWR sky130_fd_sc_hd__decap_3
XFILLER_29_72 VGND VGND VPWR VPWR sky130_fd_sc_hd__decap_3
XFILLER_48_457 VGND VGND VPWR VPWR sky130_fd_sc_hd__decap_3
XFILLER_75_243 VGND VGND VPWR VPWR sky130_fd_sc_hd__decap_3
XTAP_TAPCELL_ROW_59_964 VGND VPWR sky130_fd_sc_hd__tapvpwrvgnd_1
XFILLER_35_107 VGND VGND VPWR VPWR sky130_fd_sc_hd__decap_3
XFILLER_63_405 VGND VGND VPWR VPWR sky130_fd_sc_hd__decap_3
XFILLER_90_213 VGND VGND VPWR VPWR sky130_fd_sc_hd__decap_3
XFILLER_28_192 VGND VGND VPWR VPWR sky130_fd_sc_hd__decap_3
XFILLER_44_641 VGND VGND VPWR VPWR sky130_fd_sc_hd__decap_3
XFILLER_63_438 VGND VGND VPWR VPWR sky130_fd_sc_hd__decap_3
XFILLER_63_449 VGND VGND VPWR VPWR sky130_fd_sc_hd__decap_3
XFILLER_90_246 VGND VGND VPWR VPWR sky130_fd_sc_hd__decap_3
Xplace405 _4534_/S VGND VGND VPWR VPWR _4522_/S sky130_fd_sc_hd__buf_2
Xplace416 _4419_/B1 VGND VGND VPWR VPWR _4354_/B1 sky130_fd_sc_hd__buf_2
Xplace427 _4414_/B1 VGND VGND VPWR VPWR _3947_/S sky130_fd_sc_hd__buf_2
Xplace438 _3366_/X VGND VGND VPWR VPWR _4348_/A2 sky130_fd_sc_hd__buf_2
XTAP_TAPCELL_ROW_3_291 VGND VPWR sky130_fd_sc_hd__tapvpwrvgnd_1
XFILLER_16_365 VGND VGND VPWR VPWR sky130_fd_sc_hd__decap_3
XFILLER_43_151 VGND VGND VPWR VPWR sky130_fd_sc_hd__decap_3
XFILLER_45_60 VGND VGND VPWR VPWR sky130_fd_sc_hd__fill_2
XFILLER_45_82 VGND VGND VPWR VPWR sky130_fd_sc_hd__decap_3
Xplace449 _3318_/B VGND VGND VPWR VPWR _4307_/A2 sky130_fd_sc_hd__buf_2
XFILLER_43_184 VGND VGND VPWR VPWR sky130_fd_sc_hd__decap_3
XFILLER_71_493 VGND VGND VPWR VPWR sky130_fd_sc_hd__fill_1
XFILLER_31_346 VGND VGND VPWR VPWR sky130_fd_sc_hd__decap_3
XFILLER_31_357 VGND VGND VPWR VPWR sky130_fd_sc_hd__fill_1
XFILLER_77_6 VGND VGND VPWR VPWR sky130_fd_sc_hd__decap_3
XANTENNA_3 _5642_/B VGND VGND VPWR VPWR sky130_fd_sc_hd__diode_2
XFILLER_6_32 VGND VGND VPWR VPWR sky130_fd_sc_hd__decap_3
XFILLER_8_597 VGND VGND VPWR VPWR sky130_fd_sc_hd__fill_2
XFILLER_6_76 VGND VGND VPWR VPWR sky130_fd_sc_hd__fill_2
X_4360_ _5072_/B _5071_/B VGND VGND VPWR VPWR _5073_/A sky130_fd_sc_hd__nand2_2
XFILLER_6_98 VGND VGND VPWR VPWR sky130_fd_sc_hd__fill_1
X_3311_ _5118_/C _4696_/B _3340_/B VGND VGND VPWR VPWR _5671_/A sky130_fd_sc_hd__o21ai_2
XFILLER_98_302 VGND VGND VPWR VPWR sky130_fd_sc_hd__decap_3
XFILLER_113_646 VGND VGND VPWR VPWR sky130_fd_sc_hd__fill_1
X_4291_ _4291_/A _4612_/B VGND VGND VPWR VPWR _4292_/C sky130_fd_sc_hd__xnor2_2
XFILLER_98_335 VGND VGND VPWR VPWR sky130_fd_sc_hd__fill_2
XFILLER_112_167 VGND VGND VPWR VPWR sky130_fd_sc_hd__fill_1
XFILLER_39_402 VGND VGND VPWR VPWR sky130_fd_sc_hd__decap_3
XFILLER_112_189 VGND VGND VPWR VPWR sky130_fd_sc_hd__decap_3
XFILLER_79_571 VGND VGND VPWR VPWR sky130_fd_sc_hd__decap_3
XFILLER_66_221 VGND VGND VPWR VPWR sky130_fd_sc_hd__decap_3
XFILLER_94_530 VGND VGND VPWR VPWR sky130_fd_sc_hd__fill_2
XFILLER_26_118 VGND VGND VPWR VPWR sky130_fd_sc_hd__decap_3
XFILLER_54_427 VGND VGND VPWR VPWR sky130_fd_sc_hd__decap_3
XFILLER_66_265 VGND VGND VPWR VPWR sky130_fd_sc_hd__decap_3
XFILLER_81_202 VGND VGND VPWR VPWR sky130_fd_sc_hd__decap_3
XFILLER_94_574 VGND VGND VPWR VPWR sky130_fd_sc_hd__decap_3
XFILLER_19_181 VGND VGND VPWR VPWR sky130_fd_sc_hd__fill_2
XFILLER_35_641 VGND VGND VPWR VPWR sky130_fd_sc_hd__decap_3
XFILLER_66_298 VGND VGND VPWR VPWR sky130_fd_sc_hd__decap_3
XFILLER_81_246 VGND VGND VPWR VPWR sky130_fd_sc_hd__fill_2
Xclkbuf_leaf_46_clk clkbuf_leaf_1_clk/A VGND VGND VPWR VPWR clkload9/A sky130_fd_sc_hd__clkbuf_16
X_6932_ _7390_/CLK _6932_/D VGND VGND VPWR VPWR _6932_/Q sky130_fd_sc_hd__dfxtp_2
XFILLER_62_460 VGND VGND VPWR VPWR sky130_fd_sc_hd__decap_3
XFILLER_81_257 VGND VGND VPWR VPWR sky130_fd_sc_hd__decap_3
X_6863_ _6929_/CLK _6863_/D VGND VGND VPWR VPWR _6863_/Q sky130_fd_sc_hd__dfxtp_2
XFILLER_22_302 VGND VGND VPWR VPWR sky130_fd_sc_hd__decap_3
XFILLER_34_173 VGND VGND VPWR VPWR sky130_fd_sc_hd__decap_3
XFILLER_22_357 VGND VGND VPWR VPWR sky130_fd_sc_hd__decap_3
XFILLER_22_368 VGND VGND VPWR VPWR sky130_fd_sc_hd__decap_3
X_6794_ _7384_/CLK _6794_/D VGND VGND VPWR VPWR _6794_/Q sky130_fd_sc_hd__dfxtp_2
X_5676_ _7344_/Q hold929/X _5706_/S VGND VGND VPWR VPWR _6688_/D sky130_fd_sc_hd__mux2_2
X_4627_ _4627_/A VGND VGND VPWR VPWR _4627_/Y sky130_fd_sc_hd__inv_2
X_7346_ clkload1/A _7346_/D _6626_/Y VGND VGND VPWR VPWR _7346_/Q sky130_fd_sc_hd__dfrtp_2
XFILLER_1_217 VGND VGND VPWR VPWR sky130_fd_sc_hd__decap_3
X_7277_ _7340_/CLK _7277_/D _6557_/Y VGND VGND VPWR VPWR _7277_/Q sky130_fd_sc_hd__dfrtp_2
Xhold597 _6932_/Q VGND VGND VPWR VPWR _6932_/D sky130_fd_sc_hd__dlygate4sd3_1
X_3509_ _5640_/B _3509_/B VGND VGND VPWR VPWR _3509_/Y sky130_fd_sc_hd__nor2_2
XFILLER_103_156 VGND VGND VPWR VPWR sky130_fd_sc_hd__decap_3
XFILLER_77_508 VGND VGND VPWR VPWR sky130_fd_sc_hd__decap_3
XFILLER_89_368 VGND VGND VPWR VPWR sky130_fd_sc_hd__decap_3
XFILLER_106_55 VGND VGND VPWR VPWR sky130_fd_sc_hd__decap_3
XFILLER_106_77 VGND VGND VPWR VPWR sky130_fd_sc_hd__decap_3
XFILLER_66_15 VGND VGND VPWR VPWR sky130_fd_sc_hd__decap_3
XFILLER_66_26 VGND VGND VPWR VPWR sky130_fd_sc_hd__fill_2
XFILLER_106_99 VGND VGND VPWR VPWR sky130_fd_sc_hd__fill_1
XFILLER_57_243 VGND VGND VPWR VPWR sky130_fd_sc_hd__decap_3
XFILLER_66_59 VGND VGND VPWR VPWR sky130_fd_sc_hd__decap_3
XFILLER_18_619 VGND VGND VPWR VPWR sky130_fd_sc_hd__fill_1
XFILLER_45_405 VGND VGND VPWR VPWR sky130_fd_sc_hd__decap_3
XFILLER_57_287 VGND VGND VPWR VPWR sky130_fd_sc_hd__decap_3
XTAP_TAPCELL_ROW_56_923 VGND VPWR sky130_fd_sc_hd__tapvpwrvgnd_1
XFILLER_45_449 VGND VGND VPWR VPWR sky130_fd_sc_hd__decap_3
XFILLER_72_246 VGND VGND VPWR VPWR sky130_fd_sc_hd__decap_3
Xclkbuf_leaf_37_clk clkbuf_3_2__f_clk/X VGND VGND VPWR VPWR _7351_/CLK sky130_fd_sc_hd__clkbuf_16
XFILLER_26_674 VGND VGND VPWR VPWR sky130_fd_sc_hd__fill_1
XFILLER_72_268 VGND VGND VPWR VPWR sky130_fd_sc_hd__decap_3
XFILLER_82_47 VGND VGND VPWR VPWR sky130_fd_sc_hd__decap_3
XTAP_TAPCELL_ROW_0_250 VGND VPWR sky130_fd_sc_hd__tapvpwrvgnd_1
XFILLER_25_162 VGND VGND VPWR VPWR sky130_fd_sc_hd__fill_1
XFILLER_25_184 VGND VGND VPWR VPWR sky130_fd_sc_hd__decap_3
XFILLER_53_493 VGND VGND VPWR VPWR sky130_fd_sc_hd__decap_3
XTAP_TAPCELL_ROW_36_680 VGND VPWR sky130_fd_sc_hd__tapvpwrvgnd_1
XFILLER_13_335 VGND VGND VPWR VPWR sky130_fd_sc_hd__fill_1
XFILLER_15_74 VGND VGND VPWR VPWR sky130_fd_sc_hd__decap_3
XFILLER_40_121 VGND VGND VPWR VPWR sky130_fd_sc_hd__decap_3
XFILLER_40_165 VGND VGND VPWR VPWR sky130_fd_sc_hd__decap_3
XTAP_TAPCELL_ROW_97_1413 VGND VPWR sky130_fd_sc_hd__tapvpwrvgnd_1
XFILLER_107_473 VGND VGND VPWR VPWR sky130_fd_sc_hd__decap_3
XFILLER_110_605 VGND VGND VPWR VPWR sky130_fd_sc_hd__decap_3
XTAP_TAPCELL_ROW_8_350 VGND VPWR sky130_fd_sc_hd__tapvpwrvgnd_1
XFILLER_0_272 VGND VGND VPWR VPWR sky130_fd_sc_hd__decap_3
XFILLER_95_327 VGND VGND VPWR VPWR sky130_fd_sc_hd__fill_2
XFILLER_48_232 VGND VGND VPWR VPWR sky130_fd_sc_hd__decap_3
XFILLER_95_349 VGND VGND VPWR VPWR sky130_fd_sc_hd__decap_3
XFILLER_48_265 VGND VGND VPWR VPWR sky130_fd_sc_hd__decap_3
XFILLER_91_511 VGND VGND VPWR VPWR sky130_fd_sc_hd__decap_3
XFILLER_36_449 VGND VGND VPWR VPWR sky130_fd_sc_hd__decap_3
XFILLER_63_235 VGND VGND VPWR VPWR sky130_fd_sc_hd__decap_3
XFILLER_63_246 VGND VGND VPWR VPWR sky130_fd_sc_hd__decap_3
Xclkbuf_leaf_28_clk clkbuf_3_3__f_clk/X VGND VGND VPWR VPWR _6936_/CLK sky130_fd_sc_hd__clkbuf_16
XTAP_TAPCELL_ROW_106_1520 VGND VPWR sky130_fd_sc_hd__tapvpwrvgnd_1
XFILLER_51_408 VGND VGND VPWR VPWR sky130_fd_sc_hd__decap_3
XFILLER_63_257 VGND VGND VPWR VPWR sky130_fd_sc_hd__fill_1
XFILLER_16_162 VGND VGND VPWR VPWR sky130_fd_sc_hd__decap_3
XFILLER_32_622 VGND VGND VPWR VPWR sky130_fd_sc_hd__decap_3
XFILLER_44_471 VGND VGND VPWR VPWR sky130_fd_sc_hd__decap_3
Xplace279 _3912_/A2 VGND VGND VPWR VPWR _3926_/A2 sky130_fd_sc_hd__buf_2
Xplace268 _5651_/A VGND VGND VPWR VPWR _5660_/C sky130_fd_sc_hd__buf_2
XFILLER_16_195 VGND VGND VPWR VPWR sky130_fd_sc_hd__fill_1
XFILLER_31_143 VGND VGND VPWR VPWR sky130_fd_sc_hd__decap_3
XFILLER_71_290 VGND VGND VPWR VPWR sky130_fd_sc_hd__decap_3
X_3860_ _3860_/A0 _3859_/X _3864_/S VGND VGND VPWR VPWR _7386_/D sky130_fd_sc_hd__mux2_2
XFILLER_31_176 VGND VGND VPWR VPWR sky130_fd_sc_hd__decap_3
XFILLER_72_91 VGND VGND VPWR VPWR sky130_fd_sc_hd__fill_1
X_3791_ _3775_/X _3790_/X _5138_/S VGND VGND VPWR VPWR _4961_/A sky130_fd_sc_hd__o21a_2
XFILLER_75_3 VGND VGND VPWR VPWR sky130_fd_sc_hd__decap_3
XFILLER_8_361 VGND VGND VPWR VPWR sky130_fd_sc_hd__decap_3
X_7200_ _7401_/CLK _7200_/D _6480_/Y VGND VGND VPWR VPWR _7200_/Q sky130_fd_sc_hd__dfrtp_2
X_4412_ _4788_/B _4412_/B VGND VGND VPWR VPWR _4413_/A sky130_fd_sc_hd__or2_2
X_5392_ _5392_/A0 _4945_/X _5398_/S VGND VGND VPWR VPWR _7137_/D sky130_fd_sc_hd__mux2_2
X_7131_ clkload6/A _7131_/D _6411_/Y VGND VGND VPWR VPWR _7131_/Q sky130_fd_sc_hd__dfrtp_2
X_4343_ _4365_/C _4365_/A _4365_/B VGND VGND VPWR VPWR _4343_/X sky130_fd_sc_hd__and3b_2
XPHY_EDGE_ROW_99_Right_99 VGND VGND VPWR VPWR sky130_fd_sc_hd__decap_3
XFILLER_98_110 VGND VGND VPWR VPWR sky130_fd_sc_hd__fill_2
XFILLER_59_508 VGND VGND VPWR VPWR sky130_fd_sc_hd__decap_3
X_7062_ clkload5/A _7062_/D _6342_/Y VGND VGND VPWR VPWR _7062_/Q sky130_fd_sc_hd__dfrtp_2
X_4274_ _4376_/A _4376_/B _4376_/C _4273_/D VGND VGND VPWR VPWR _4274_/Y sky130_fd_sc_hd__o31ai_2
XFILLER_98_154 VGND VGND VPWR VPWR sky130_fd_sc_hd__fill_1
XFILLER_101_638 VGND VGND VPWR VPWR sky130_fd_sc_hd__decap_3
XFILLER_113_487 VGND VGND VPWR VPWR sky130_fd_sc_hd__fill_2
XFILLER_86_327 VGND VGND VPWR VPWR sky130_fd_sc_hd__decap_3
XFILLER_100_126 VGND VGND VPWR VPWR sky130_fd_sc_hd__decap_3
XFILLER_100_159 VGND VGND VPWR VPWR sky130_fd_sc_hd__decap_3
XFILLER_39_221 VGND VGND VPWR VPWR sky130_fd_sc_hd__decap_3
XFILLER_67_541 VGND VGND VPWR VPWR sky130_fd_sc_hd__decap_3
XFILLER_79_390 VGND VGND VPWR VPWR sky130_fd_sc_hd__fill_2
XFILLER_67_585 VGND VGND VPWR VPWR sky130_fd_sc_hd__decap_3
XFILLER_27_449 VGND VGND VPWR VPWR sky130_fd_sc_hd__decap_3
XFILLER_36_29 VGND VGND VPWR VPWR sky130_fd_sc_hd__decap_3
XFILLER_54_224 VGND VGND VPWR VPWR sky130_fd_sc_hd__decap_3
XFILLER_82_533 VGND VGND VPWR VPWR sky130_fd_sc_hd__fill_2
XFILLER_94_382 VGND VGND VPWR VPWR sky130_fd_sc_hd__decap_3
Xclkbuf_leaf_19_clk clkbuf_3_6__f_clk/X VGND VGND VPWR VPWR _7406_/CLK sky130_fd_sc_hd__clkbuf_16
XPHY_EDGE_ROW_6_Left_123 VGND VGND VPWR VPWR sky130_fd_sc_hd__decap_3
XFILLER_42_419 VGND VGND VPWR VPWR sky130_fd_sc_hd__fill_1
XFILLER_82_577 VGND VGND VPWR VPWR sky130_fd_sc_hd__decap_3
X_6915_ _6936_/CLK _6915_/D VGND VGND VPWR VPWR _6915_/Q sky130_fd_sc_hd__dfxtp_2
XTAP_TAPCELL_ROW_68_1069 VGND VPWR sky130_fd_sc_hd__tapvpwrvgnd_1
XTAP_TAPCELL_ROW_81_1225 VGND VPWR sky130_fd_sc_hd__tapvpwrvgnd_1
XFILLER_50_441 VGND VGND VPWR VPWR sky130_fd_sc_hd__decap_3
XFILLER_62_290 VGND VGND VPWR VPWR sky130_fd_sc_hd__decap_3
X_6846_ _6929_/CLK _6846_/D VGND VGND VPWR VPWR _6846_/Q sky130_fd_sc_hd__dfxtp_2
XFILLER_22_165 VGND VGND VPWR VPWR sky130_fd_sc_hd__decap_3
XFILLER_50_463 VGND VGND VPWR VPWR sky130_fd_sc_hd__decap_3
X_6777_ _7383_/CLK _6777_/D VGND VGND VPWR VPWR _6777_/Q sky130_fd_sc_hd__dfxtp_2
XTAP_TAPCELL_ROW_61_981 VGND VPWR sky130_fd_sc_hd__tapvpwrvgnd_1
XTAP_TAPCELL_ROW_33_650 VGND VPWR sky130_fd_sc_hd__tapvpwrvgnd_1
X_3989_ _7346_/Q _4530_/A0 _3989_/S VGND VGND VPWR VPWR _7346_/D sky130_fd_sc_hd__mux2_2
XFILLER_108_226 VGND VGND VPWR VPWR sky130_fd_sc_hd__decap_3
XFILLER_108_237 VGND VGND VPWR VPWR sky130_fd_sc_hd__decap_3
X_5659_ _5659_/A _5659_/B VGND VGND VPWR VPWR _5660_/D sky130_fd_sc_hd__nor2_2
XTAP_TAPCELL_ROW_79_1198 VGND VPWR sky130_fd_sc_hd__tapvpwrvgnd_1
XFILLER_104_421 VGND VGND VPWR VPWR sky130_fd_sc_hd__fill_1
XFILLER_116_292 VGND VGND VPWR VPWR sky130_fd_sc_hd__decap_3
XFILLER_7_6 VGND VGND VPWR VPWR sky130_fd_sc_hd__decap_3
X_7329_ _7363_/CLK _7329_/D _6609_/Y VGND VGND VPWR VPWR _7329_/Q sky130_fd_sc_hd__dfrtp_2
XTAP_TAPCELL_ROW_92_1354 VGND VPWR sky130_fd_sc_hd__tapvpwrvgnd_1
XFILLER_104_454 VGND VGND VPWR VPWR sky130_fd_sc_hd__fill_1
XFILLER_89_154 VGND VGND VPWR VPWR sky130_fd_sc_hd__decap_3
XFILLER_77_69 VGND VGND VPWR VPWR sky130_fd_sc_hd__decap_3
XFILLER_77_349 VGND VGND VPWR VPWR sky130_fd_sc_hd__decap_3
XFILLER_73_511 VGND VGND VPWR VPWR sky130_fd_sc_hd__decap_3
Xhold1050 _7198_/Q VGND VGND VPWR VPWR _5264_/A0 sky130_fd_sc_hd__dlygate4sd3_1
XFILLER_45_213 VGND VGND VPWR VPWR sky130_fd_sc_hd__decap_3
XFILLER_85_393 VGND VGND VPWR VPWR sky130_fd_sc_hd__decap_3
XFILLER_93_46 VGND VGND VPWR VPWR sky130_fd_sc_hd__fill_2
XFILLER_93_57 VGND VGND VPWR VPWR sky130_fd_sc_hd__decap_3
Xhold1061 _7244_/Q VGND VGND VPWR VPWR _5167_/A sky130_fd_sc_hd__dlygate4sd3_1
Xhold1072 _7227_/Q VGND VGND VPWR VPWR _5203_/A sky130_fd_sc_hd__dlygate4sd3_1
Xhold1083 _7264_/Q VGND VGND VPWR VPWR _4965_/A0 sky130_fd_sc_hd__dlygate4sd3_1
Xhold1094 _7378_/Q VGND VGND VPWR VPWR _3915_/A0 sky130_fd_sc_hd__dlygate4sd3_1
XFILLER_33_408 VGND VGND VPWR VPWR sky130_fd_sc_hd__decap_3
XFILLER_93_79 VGND VGND VPWR VPWR sky130_fd_sc_hd__decap_3
XFILLER_14_622 VGND VGND VPWR VPWR sky130_fd_sc_hd__decap_3
XFILLER_26_73 VGND VGND VPWR VPWR sky130_fd_sc_hd__decap_3
XFILLER_60_238 VGND VGND VPWR VPWR sky130_fd_sc_hd__decap_3
XFILLER_13_110 VGND VGND VPWR VPWR sky130_fd_sc_hd__fill_2
XFILLER_14_633 VGND VGND VPWR VPWR sky130_fd_sc_hd__decap_3
XFILLER_26_95 VGND VGND VPWR VPWR sky130_fd_sc_hd__decap_3
XFILLER_53_290 VGND VGND VPWR VPWR sky130_fd_sc_hd__decap_3
XFILLER_41_463 VGND VGND VPWR VPWR sky130_fd_sc_hd__decap_3
XFILLER_9_125 VGND VGND VPWR VPWR sky130_fd_sc_hd__decap_3
XFILLER_13_187 VGND VGND VPWR VPWR sky130_fd_sc_hd__decap_3
XTAP_TAPCELL_ROW_101_1461 VGND VPWR sky130_fd_sc_hd__tapvpwrvgnd_1
XFILLER_9_158 VGND VGND VPWR VPWR sky130_fd_sc_hd__decap_3
XFILLER_42_94 VGND VGND VPWR VPWR sky130_fd_sc_hd__decap_3
XFILLER_9_169 VGND VGND VPWR VPWR sky130_fd_sc_hd__decap_3
XFILLER_5_320 VGND VGND VPWR VPWR sky130_fd_sc_hd__decap_3
XFILLER_61_9 VGND VGND VPWR VPWR sky130_fd_sc_hd__decap_3
XTAP_TAPCELL_ROW_11_388 VGND VPWR sky130_fd_sc_hd__tapvpwrvgnd_1
XFILLER_5_364 VGND VGND VPWR VPWR sky130_fd_sc_hd__decap_3
XFILLER_107_281 VGND VGND VPWR VPWR sky130_fd_sc_hd__decap_3
XFILLER_110_413 VGND VGND VPWR VPWR sky130_fd_sc_hd__decap_3
XFILLER_110_424 VGND VGND VPWR VPWR sky130_fd_sc_hd__decap_3
XFILLER_68_327 VGND VGND VPWR VPWR sky130_fd_sc_hd__decap_3
XFILLER_68_338 VGND VGND VPWR VPWR sky130_fd_sc_hd__decap_3
XFILLER_96_625 VGND VGND VPWR VPWR sky130_fd_sc_hd__fill_1
XFILLER_110_457 VGND VGND VPWR VPWR sky130_fd_sc_hd__decap_3
XFILLER_95_124 VGND VGND VPWR VPWR sky130_fd_sc_hd__decap_3
XFILLER_95_157 VGND VGND VPWR VPWR sky130_fd_sc_hd__decap_3
XTAP_TAPCELL_ROW_112_1590 VGND VPWR sky130_fd_sc_hd__tapvpwrvgnd_1
XPHY_EDGE_ROW_79_Left_196 VGND VGND VPWR VPWR sky130_fd_sc_hd__decap_3
XFILLER_64_500 VGND VGND VPWR VPWR sky130_fd_sc_hd__decap_3
XFILLER_36_213 VGND VGND VPWR VPWR sky130_fd_sc_hd__decap_3
XFILLER_64_522 VGND VGND VPWR VPWR sky130_fd_sc_hd__decap_3
XFILLER_64_533 VGND VGND VPWR VPWR sky130_fd_sc_hd__decap_3
XFILLER_76_371 VGND VGND VPWR VPWR sky130_fd_sc_hd__decap_3
XFILLER_36_279 VGND VGND VPWR VPWR sky130_fd_sc_hd__decap_3
XFILLER_64_599 VGND VGND VPWR VPWR sky130_fd_sc_hd__decap_3
XFILLER_91_396 VGND VGND VPWR VPWR sky130_fd_sc_hd__decap_3
X_4961_ _4961_/A _5662_/C _4961_/C VGND VGND VPWR VPWR _4961_/X sky130_fd_sc_hd__or3_4
XTAP_TAPCELL_ROW_19_477 VGND VPWR sky130_fd_sc_hd__tapvpwrvgnd_1
X_6700_ _7383_/CLK _6700_/D VGND VGND VPWR VPWR _6700_/Q sky130_fd_sc_hd__dfxtp_2
X_4892_ _4884_/X _4886_/X _4887_/Y _4891_/X VGND VGND VPWR VPWR _5656_/B sky130_fd_sc_hd__a31o_2
X_3912_ _6905_/Q _3912_/A2 _3912_/B1 _6897_/Q VGND VGND VPWR VPWR _3912_/X sky130_fd_sc_hd__a22o_2
X_6631_ _6635_/A VGND VGND VPWR VPWR _6631_/Y sky130_fd_sc_hd__inv_2
X_3843_ _6699_/Q _5660_/B _3852_/B1 _6877_/Q _3842_/X VGND VGND VPWR VPWR _3843_/X
+ sky130_fd_sc_hd__a221o_2
X_6562_ _6562_/A VGND VGND VPWR VPWR _6562_/Y sky130_fd_sc_hd__inv_2
X_3774_ _6757_/Q _3913_/B1 _3912_/B1 _6769_/Q _3773_/X VGND VGND VPWR VPWR _3774_/X
+ sky130_fd_sc_hd__a221o_2
XFILLER_8_180 VGND VGND VPWR VPWR sky130_fd_sc_hd__decap_3
X_6493_ _6651_/A VGND VGND VPWR VPWR _6493_/Y sky130_fd_sc_hd__inv_2
Xclkbuf_leaf_8_clk clkbuf_leaf_9_clk/A VGND VGND VPWR VPWR _7359_/CLK sky130_fd_sc_hd__clkbuf_16
X_7114_ _7307_/CLK _7114_/D _6394_/Y VGND VGND VPWR VPWR _7114_/Q sky130_fd_sc_hd__dfrtp_2
Xoutput477 place75/X VGND VGND VPWR VPWR alu_result_out[20] sky130_fd_sc_hd__clkdlybuf4s25_1
Xoutput466 _5658_/A VGND VGND VPWR VPWR alu_result_out[10] sky130_fd_sc_hd__clkdlybuf4s25_1
X_5375_ _5375_/A0 _4806_/X _5383_/S VGND VGND VPWR VPWR _7145_/D sky130_fd_sc_hd__mux2_2
XFILLER_99_452 VGND VGND VPWR VPWR sky130_fd_sc_hd__decap_3
XFILLER_99_441 VGND VGND VPWR VPWR sky130_fd_sc_hd__decap_3
XFILLER_101_402 VGND VGND VPWR VPWR sky130_fd_sc_hd__decap_3
XFILLER_101_424 VGND VGND VPWR VPWR sky130_fd_sc_hd__decap_3
XFILLER_113_262 VGND VGND VPWR VPWR sky130_fd_sc_hd__decap_3
XFILLER_59_305 VGND VGND VPWR VPWR sky130_fd_sc_hd__decap_3
Xoutput499 _5645_/X VGND VGND VPWR VPWR instruction_out[12] sky130_fd_sc_hd__clkdlybuf4s25_1
Xoutput488 _5655_/A VGND VGND VPWR VPWR alu_result_out[30] sky130_fd_sc_hd__clkdlybuf4s25_1
X_4326_ _7013_/Q _3358_/X _4322_/X _4325_/X VGND VGND VPWR VPWR _4327_/B sky130_fd_sc_hd__a211o_2
XFILLER_99_485 VGND VGND VPWR VPWR sky130_fd_sc_hd__decap_3
XFILLER_113_284 VGND VGND VPWR VPWR sky130_fd_sc_hd__decap_3
XFILLER_59_349 VGND VGND VPWR VPWR sky130_fd_sc_hd__decap_3
XFILLER_86_124 VGND VGND VPWR VPWR sky130_fd_sc_hd__decap_3
X_7045_ _7401_/CLK _7045_/D _6325_/Y VGND VGND VPWR VPWR _7045_/Q sky130_fd_sc_hd__dfrtp_2
X_4257_ _4626_/B _4626_/C _4256_/C VGND VGND VPWR VPWR _4988_/B sky130_fd_sc_hd__a21oi_2
XFILLER_47_39 VGND VGND VPWR VPWR sky130_fd_sc_hd__decap_3
X_4188_ _7359_/Q _4196_/A2 _4187_/X _4188_/C1 VGND VGND VPWR VPWR _4188_/X sky130_fd_sc_hd__a211o_2
XFILLER_27_246 VGND VGND VPWR VPWR sky130_fd_sc_hd__fill_1
XFILLER_55_555 VGND VGND VPWR VPWR sky130_fd_sc_hd__decap_3
XFILLER_82_352 VGND VGND VPWR VPWR sky130_fd_sc_hd__decap_3
XFILLER_70_514 VGND VGND VPWR VPWR sky130_fd_sc_hd__decap_3
XFILLER_70_536 VGND VGND VPWR VPWR sky130_fd_sc_hd__decap_3
XFILLER_42_249 VGND VGND VPWR VPWR sky130_fd_sc_hd__decap_3
XFILLER_11_614 VGND VGND VPWR VPWR sky130_fd_sc_hd__fill_2
XFILLER_23_452 VGND VGND VPWR VPWR sky130_fd_sc_hd__decap_3
X_6829_ _6909_/CLK _6829_/D VGND VGND VPWR VPWR _6829_/Q sky130_fd_sc_hd__dfxtp_2
XFILLER_10_124 VGND VGND VPWR VPWR sky130_fd_sc_hd__decap_3
XFILLER_11_658 VGND VGND VPWR VPWR sky130_fd_sc_hd__decap_3
XFILLER_50_282 VGND VGND VPWR VPWR sky130_fd_sc_hd__decap_3
XFILLER_109_535 VGND VGND VPWR VPWR sky130_fd_sc_hd__decap_3
XFILLER_12_53 VGND VGND VPWR VPWR sky130_fd_sc_hd__decap_3
XFILLER_104_240 VGND VGND VPWR VPWR sky130_fd_sc_hd__decap_3
XFILLER_5_3 VGND VGND VPWR VPWR sky130_fd_sc_hd__decap_3
XFILLER_77_113 VGND VGND VPWR VPWR sky130_fd_sc_hd__fill_2
XFILLER_78_625 VGND VGND VPWR VPWR sky130_fd_sc_hd__decap_3
XFILLER_104_284 VGND VGND VPWR VPWR sky130_fd_sc_hd__decap_3
XFILLER_78_658 VGND VGND VPWR VPWR sky130_fd_sc_hd__decap_3
XFILLER_65_319 VGND VGND VPWR VPWR sky130_fd_sc_hd__decap_3
XFILLER_93_617 VGND VGND VPWR VPWR sky130_fd_sc_hd__decap_3
XFILLER_93_639 VGND VGND VPWR VPWR sky130_fd_sc_hd__fill_1
XFILLER_18_224 VGND VGND VPWR VPWR sky130_fd_sc_hd__decap_3
XFILLER_46_522 VGND VGND VPWR VPWR sky130_fd_sc_hd__decap_3
XFILLER_46_533 VGND VGND VPWR VPWR sky130_fd_sc_hd__decap_3
XFILLER_92_127 VGND VGND VPWR VPWR sky130_fd_sc_hd__decap_3
XFILLER_18_235 VGND VGND VPWR VPWR sky130_fd_sc_hd__decap_3
XFILLER_18_268 VGND VGND VPWR VPWR sky130_fd_sc_hd__decap_3
XFILLER_37_94 VGND VGND VPWR VPWR sky130_fd_sc_hd__decap_3
XFILLER_73_352 VGND VGND VPWR VPWR sky130_fd_sc_hd__decap_3
XFILLER_33_205 VGND VGND VPWR VPWR sky130_fd_sc_hd__decap_3
XFILLER_33_216 VGND VGND VPWR VPWR sky130_fd_sc_hd__decap_3
XFILLER_73_374 VGND VGND VPWR VPWR sky130_fd_sc_hd__decap_3
XFILLER_14_430 VGND VGND VPWR VPWR sky130_fd_sc_hd__decap_3
XFILLER_26_290 VGND VGND VPWR VPWR sky130_fd_sc_hd__decap_3
XFILLER_61_558 VGND VGND VPWR VPWR sky130_fd_sc_hd__fill_2
XTAP_TAPCELL_ROW_16_447 VGND VPWR sky130_fd_sc_hd__tapvpwrvgnd_1
XFILLER_53_60 VGND VGND VPWR VPWR sky130_fd_sc_hd__decap_3
XTAP_TAPCELL_ROW_44_778 VGND VPWR sky130_fd_sc_hd__tapvpwrvgnd_1
XFILLER_41_271 VGND VGND VPWR VPWR sky130_fd_sc_hd__decap_3
XFILLER_41_293 VGND VGND VPWR VPWR sky130_fd_sc_hd__decap_3
XFILLER_53_93 VGND VGND VPWR VPWR sky130_fd_sc_hd__decap_3
XFILLER_115_505 VGND VGND VPWR VPWR sky130_fd_sc_hd__fill_2
X_3490_ _7119_/Q _4246_/B1 _3489_/X _4248_/A VGND VGND VPWR VPWR _3490_/X sky130_fd_sc_hd__a211o_2
XFILLER_5_161 VGND VGND VPWR VPWR sky130_fd_sc_hd__decap_3
XFILLER_5_172 VGND VGND VPWR VPWR sky130_fd_sc_hd__decap_3
XFILLER_38_3 VGND VGND VPWR VPWR sky130_fd_sc_hd__decap_3
XFILLER_68_113 VGND VGND VPWR VPWR sky130_fd_sc_hd__decap_3
XFILLER_96_400 VGND VGND VPWR VPWR sky130_fd_sc_hd__decap_3
XPHY_EDGE_ROW_87_Left_204 VGND VGND VPWR VPWR sky130_fd_sc_hd__decap_3
X_5091_ _6985_/Q _5068_/C _6986_/Q VGND VGND VPWR VPWR _5092_/B sky130_fd_sc_hd__a21o_2
X_4111_ _4109_/X _4111_/B VGND VGND VPWR VPWR _4845_/A sky130_fd_sc_hd__nand2b_2
XFILLER_68_179 VGND VGND VPWR VPWR sky130_fd_sc_hd__decap_3
XFILLER_96_477 VGND VGND VPWR VPWR sky130_fd_sc_hd__decap_3
X_4042_ _7341_/Q _3943_/S _4399_/A2 _7373_/Q _4429_/C1 VGND VGND VPWR VPWR _4042_/X
+ sky130_fd_sc_hd__a221o_2
XFILLER_37_511 VGND VGND VPWR VPWR sky130_fd_sc_hd__decap_3
XFILLER_77_691 VGND VGND VPWR VPWR sky130_fd_sc_hd__fill_1
XFILLER_84_639 VGND VGND VPWR VPWR sky130_fd_sc_hd__decap_3
XFILLER_64_341 VGND VGND VPWR VPWR sky130_fd_sc_hd__decap_3
XFILLER_24_227 VGND VGND VPWR VPWR sky130_fd_sc_hd__decap_3
XFILLER_52_514 VGND VGND VPWR VPWR sky130_fd_sc_hd__decap_3
XFILLER_64_374 VGND VGND VPWR VPWR sky130_fd_sc_hd__decap_3
XTAP_TAPCELL_ROW_65_1028 VGND VPWR sky130_fd_sc_hd__tapvpwrvgnd_1
X_4944_ _5010_/A _4944_/B _4944_/C VGND VGND VPWR VPWR _4944_/X sky130_fd_sc_hd__or3_2
XPHY_EDGE_ROW_96_Left_213 VGND VGND VPWR VPWR sky130_fd_sc_hd__decap_3
X_4875_ _4842_/X _4871_/Y _4874_/X VGND VGND VPWR VPWR _5663_/C sky130_fd_sc_hd__a21bo_2
X_6614_ _6616_/A VGND VGND VPWR VPWR _6614_/Y sky130_fd_sc_hd__inv_2
X_3826_ _6731_/Q _3826_/A2 _3827_/B1 _6743_/Q _3825_/X VGND VGND VPWR VPWR _3826_/X
+ sky130_fd_sc_hd__a221o_2
XFILLER_20_477 VGND VGND VPWR VPWR sky130_fd_sc_hd__decap_3
XFILLER_20_499 VGND VGND VPWR VPWR sky130_fd_sc_hd__fill_1
X_6545_ _6578_/A VGND VGND VPWR VPWR _6545_/Y sky130_fd_sc_hd__inv_2
X_3757_ _7396_/Q _3756_/X _3757_/S VGND VGND VPWR VPWR _7396_/D sky130_fd_sc_hd__mux2_2
XFILLER_106_505 VGND VGND VPWR VPWR sky130_fd_sc_hd__decap_3
XFILLER_109_9 VGND VGND VPWR VPWR sky130_fd_sc_hd__decap_3
X_6476_ _6644_/A VGND VGND VPWR VPWR _6476_/Y sky130_fd_sc_hd__inv_2
X_5427_ _5427_/A0 _5156_/X _5429_/S VGND VGND VPWR VPWR _7120_/D sky130_fd_sc_hd__mux2_2
XTAP_TAPCELL_ROW_76_1168 VGND VPWR sky130_fd_sc_hd__tapvpwrvgnd_1
XFILLER_58_27 VGND VGND VPWR VPWR sky130_fd_sc_hd__fill_1
XFILLER_58_38 VGND VGND VPWR VPWR sky130_fd_sc_hd__decap_3
X_5358_ _5358_/A0 _5156_/X _5360_/S VGND VGND VPWR VPWR _7152_/D sky130_fd_sc_hd__mux2_2
XFILLER_101_210 VGND VGND VPWR VPWR sky130_fd_sc_hd__decap_3
XFILLER_59_113 VGND VGND VPWR VPWR sky130_fd_sc_hd__decap_3
X_4309_ _7128_/Q _3407_/X _4307_/X _4308_/X VGND VGND VPWR VPWR _4311_/B sky130_fd_sc_hd__a211o_2
XFILLER_99_293 VGND VGND VPWR VPWR sky130_fd_sc_hd__decap_3
XFILLER_101_254 VGND VGND VPWR VPWR sky130_fd_sc_hd__decap_3
XFILLER_47_308 VGND VGND VPWR VPWR sky130_fd_sc_hd__decap_3
XFILLER_75_606 VGND VGND VPWR VPWR sky130_fd_sc_hd__decap_3
XFILLER_75_617 VGND VGND VPWR VPWR sky130_fd_sc_hd__decap_3
X_7028_ _7381_/CLK _7028_/D _6308_/Y VGND VGND VPWR VPWR _7028_/Q sky130_fd_sc_hd__dfrtp_2
XFILLER_28_533 VGND VGND VPWR VPWR sky130_fd_sc_hd__decap_3
XFILLER_114_77 VGND VGND VPWR VPWR sky130_fd_sc_hd__decap_3
XFILLER_114_88 VGND VGND VPWR VPWR sky130_fd_sc_hd__decap_3
XFILLER_28_555 VGND VGND VPWR VPWR sky130_fd_sc_hd__decap_3
XFILLER_55_330 VGND VGND VPWR VPWR sky130_fd_sc_hd__decap_3
XFILLER_55_352 VGND VGND VPWR VPWR sky130_fd_sc_hd__decap_3
XFILLER_74_26 VGND VGND VPWR VPWR sky130_fd_sc_hd__fill_2
XFILLER_74_37 VGND VGND VPWR VPWR sky130_fd_sc_hd__decap_3
XFILLER_74_59 VGND VGND VPWR VPWR sky130_fd_sc_hd__decap_3
XFILLER_83_661 VGND VGND VPWR VPWR sky130_fd_sc_hd__decap_3
XFILLER_43_514 VGND VGND VPWR VPWR sky130_fd_sc_hd__decap_3
XFILLER_70_300 VGND VGND VPWR VPWR sky130_fd_sc_hd__decap_3
XFILLER_82_171 VGND VGND VPWR VPWR sky130_fd_sc_hd__decap_3
XFILLER_15_249 VGND VGND VPWR VPWR sky130_fd_sc_hd__decap_3
XFILLER_43_558 VGND VGND VPWR VPWR sky130_fd_sc_hd__fill_2
XFILLER_43_569 VGND VGND VPWR VPWR sky130_fd_sc_hd__fill_2
XFILLER_70_344 VGND VGND VPWR VPWR sky130_fd_sc_hd__decap_3
XTAP_TAPCELL_ROW_87_1297 VGND VPWR sky130_fd_sc_hd__tapvpwrvgnd_1
XFILLER_30_208 VGND VGND VPWR VPWR sky130_fd_sc_hd__decap_3
XFILLER_70_377 VGND VGND VPWR VPWR sky130_fd_sc_hd__decap_3
XFILLER_70_388 VGND VGND VPWR VPWR sky130_fd_sc_hd__decap_3
XFILLER_90_14 VGND VGND VPWR VPWR sky130_fd_sc_hd__decap_3
XTAP_TAPCELL_ROW_13_406 VGND VPWR sky130_fd_sc_hd__tapvpwrvgnd_1
XFILLER_11_411 VGND VGND VPWR VPWR sky130_fd_sc_hd__decap_3
XFILLER_23_30 VGND VGND VPWR VPWR sky130_fd_sc_hd__decap_3
XTAP_TAPCELL_ROW_41_748 VGND VPWR sky130_fd_sc_hd__tapvpwrvgnd_1
XFILLER_11_466 VGND VGND VPWR VPWR sky130_fd_sc_hd__decap_3
XFILLER_23_293 VGND VGND VPWR VPWR sky130_fd_sc_hd__decap_3
XFILLER_23_63 VGND VGND VPWR VPWR sky130_fd_sc_hd__decap_3
XFILLER_7_404 VGND VGND VPWR VPWR sky130_fd_sc_hd__decap_3
XFILLER_109_310 VGND VGND VPWR VPWR sky130_fd_sc_hd__decap_3
XFILLER_7_437 VGND VGND VPWR VPWR sky130_fd_sc_hd__fill_1
XFILLER_109_343 VGND VGND VPWR VPWR sky130_fd_sc_hd__decap_3
XFILLER_109_376 VGND VGND VPWR VPWR sky130_fd_sc_hd__decap_3
XFILLER_2_120 VGND VGND VPWR VPWR sky130_fd_sc_hd__fill_2
XFILLER_3_643 VGND VGND VPWR VPWR sky130_fd_sc_hd__fill_2
XFILLER_112_519 VGND VGND VPWR VPWR sky130_fd_sc_hd__decap_3
XFILLER_2_197 VGND VGND VPWR VPWR sky130_fd_sc_hd__fill_1
XFILLER_78_455 VGND VGND VPWR VPWR sky130_fd_sc_hd__decap_3
XFILLER_78_477 VGND VGND VPWR VPWR sky130_fd_sc_hd__decap_3
XFILLER_93_414 VGND VGND VPWR VPWR sky130_fd_sc_hd__decap_3
XFILLER_48_93 VGND VGND VPWR VPWR sky130_fd_sc_hd__decap_3
XFILLER_59_691 VGND VGND VPWR VPWR sky130_fd_sc_hd__fill_1
XFILLER_65_116 VGND VGND VPWR VPWR sky130_fd_sc_hd__decap_3
XTAP_TAPCELL_ROW_49_837 VGND VPWR sky130_fd_sc_hd__tapvpwrvgnd_1
XFILLER_46_330 VGND VGND VPWR VPWR sky130_fd_sc_hd__decap_3
XFILLER_81_609 VGND VGND VPWR VPWR sky130_fd_sc_hd__decap_3
XFILLER_0_78 VGND VGND VPWR VPWR sky130_fd_sc_hd__decap_3
XFILLER_34_514 VGND VGND VPWR VPWR sky130_fd_sc_hd__decap_3
XFILLER_46_363 VGND VGND VPWR VPWR sky130_fd_sc_hd__fill_1
XFILLER_46_374 VGND VGND VPWR VPWR sky130_fd_sc_hd__decap_3
XFILLER_80_119 VGND VGND VPWR VPWR sky130_fd_sc_hd__fill_1
XFILLER_0_89 VGND VGND VPWR VPWR sky130_fd_sc_hd__decap_3
XFILLER_61_333 VGND VGND VPWR VPWR sky130_fd_sc_hd__decap_3
XFILLER_73_193 VGND VGND VPWR VPWR sky130_fd_sc_hd__decap_3
XTAP_TAPCELL_ROW_29_594 VGND VPWR sky130_fd_sc_hd__tapvpwrvgnd_1
XFILLER_21_219 VGND VGND VPWR VPWR sky130_fd_sc_hd__decap_3
XFILLER_61_355 VGND VGND VPWR VPWR sky130_fd_sc_hd__decap_3
XFILLER_61_388 VGND VGND VPWR VPWR sky130_fd_sc_hd__decap_3
XFILLER_61_399 VGND VGND VPWR VPWR sky130_fd_sc_hd__decap_3
XFILLER_14_293 VGND VGND VPWR VPWR sky130_fd_sc_hd__decap_3
X_4660_ _4720_/A _4655_/X _4658_/A VGND VGND VPWR VPWR _4660_/X sky130_fd_sc_hd__a21bo_2
XFILLER_80_91 VGND VGND VPWR VPWR sky130_fd_sc_hd__decap_3
X_3611_ _5057_/A _3611_/B VGND VGND VPWR VPWR _3611_/Y sky130_fd_sc_hd__nor2_2
X_6330_ _6682_/A VGND VGND VPWR VPWR _6330_/Y sky130_fd_sc_hd__inv_2
X_4591_ _7285_/Q _4595_/B VGND VGND VPWR VPWR _7285_/D sky130_fd_sc_hd__and2_2
Xhold905 _7107_/Q VGND VGND VPWR VPWR _7107_/D sky130_fd_sc_hd__dlygate4sd3_1
Xhold916 _6711_/Q VGND VGND VPWR VPWR hold916/X sky130_fd_sc_hd__dlygate4sd3_1
Xhold927 _6705_/Q VGND VGND VPWR VPWR hold927/X sky130_fd_sc_hd__dlygate4sd3_1
XFILLER_115_335 VGND VGND VPWR VPWR sky130_fd_sc_hd__fill_1
Xhold938 _7030_/Q VGND VGND VPWR VPWR _5595_/A sky130_fd_sc_hd__dlygate4sd3_1
Xhold949 _7028_/Q VGND VGND VPWR VPWR hold949/X sky130_fd_sc_hd__dlygate4sd3_1
X_6261_ _6385_/A VGND VGND VPWR VPWR _6261_/Y sky130_fd_sc_hd__inv_2
X_3473_ _7312_/Q _3977_/S _4332_/B1 _7344_/Q _4248_/A VGND VGND VPWR VPWR _3473_/X
+ sky130_fd_sc_hd__a221o_2
XFILLER_69_411 VGND VGND VPWR VPWR sky130_fd_sc_hd__decap_3
XFILLER_88_208 VGND VGND VPWR VPWR sky130_fd_sc_hd__decap_3
XFILLER_69_444 VGND VGND VPWR VPWR sky130_fd_sc_hd__decap_3
XFILLER_96_230 VGND VGND VPWR VPWR sky130_fd_sc_hd__decap_3
XFILLER_29_319 VGND VGND VPWR VPWR sky130_fd_sc_hd__fill_1
XFILLER_57_606 VGND VGND VPWR VPWR sky130_fd_sc_hd__fill_2
XFILLER_57_617 VGND VGND VPWR VPWR sky130_fd_sc_hd__decap_3
XFILLER_69_455 VGND VGND VPWR VPWR sky130_fd_sc_hd__decap_3
XFILLER_69_477 VGND VGND VPWR VPWR sky130_fd_sc_hd__decap_3
XFILLER_56_116 VGND VGND VPWR VPWR sky130_fd_sc_hd__decap_3
XFILLER_84_414 VGND VGND VPWR VPWR sky130_fd_sc_hd__decap_3
XFILLER_96_274 VGND VGND VPWR VPWR sky130_fd_sc_hd__decap_3
X_5074_ _4852_/A _5073_/A _5073_/Y _5103_/A1 VGND VGND VPWR VPWR _5075_/C sky130_fd_sc_hd__a2bb2o_2
XTAP_TAPCELL_ROW_71_1098 VGND VPWR sky130_fd_sc_hd__tapvpwrvgnd_1
XFILLER_64_160 VGND VGND VPWR VPWR sky130_fd_sc_hd__decap_3
XFILLER_65_661 VGND VGND VPWR VPWR sky130_fd_sc_hd__decap_3
XFILLER_37_396 VGND VGND VPWR VPWR sky130_fd_sc_hd__decap_3
XFILLER_44_29 VGND VGND VPWR VPWR sky130_fd_sc_hd__decap_3
XFILLER_52_333 VGND VGND VPWR VPWR sky130_fd_sc_hd__decap_3
XFILLER_92_480 VGND VGND VPWR VPWR sky130_fd_sc_hd__decap_3
XFILLER_52_377 VGND VGND VPWR VPWR sky130_fd_sc_hd__decap_3
XFILLER_100_35 VGND VGND VPWR VPWR sky130_fd_sc_hd__decap_3
X_4927_ _5577_/S _4927_/B _5656_/C VGND VGND VPWR VPWR _4927_/X sky130_fd_sc_hd__or3_2
XFILLER_20_230 VGND VGND VPWR VPWR sky130_fd_sc_hd__decap_3
X_4858_ _6999_/Q _4858_/B VGND VGND VPWR VPWR _4870_/A sky130_fd_sc_hd__and2_2
X_3809_ _6836_/Q _3893_/A2 _3892_/B1 _6841_/Q VGND VGND VPWR VPWR _3809_/X sky130_fd_sc_hd__a22o_2
X_4789_ _5057_/A _4412_/B _4413_/A _4852_/A _4788_/Y VGND VGND VPWR VPWR _4789_/X
+ sky130_fd_sc_hd__o221a_2
XFILLER_106_324 VGND VGND VPWR VPWR sky130_fd_sc_hd__decap_3
XFILLER_109_55 VGND VGND VPWR VPWR sky130_fd_sc_hd__fill_1
X_6528_ _6640_/A VGND VGND VPWR VPWR _6528_/Y sky130_fd_sc_hd__inv_2
XFILLER_106_357 VGND VGND VPWR VPWR sky130_fd_sc_hd__decap_3
XFILLER_109_66 VGND VGND VPWR VPWR sky130_fd_sc_hd__decap_3
XFILLER_69_15 VGND VGND VPWR VPWR sky130_fd_sc_hd__decap_3
X_6459_ _6558_/A VGND VGND VPWR VPWR _6459_/Y sky130_fd_sc_hd__inv_2
XFILLER_79_219 VGND VGND VPWR VPWR sky130_fd_sc_hd__decap_3
XFILLER_48_606 VGND VGND VPWR VPWR sky130_fd_sc_hd__decap_3
XFILLER_85_14 VGND VGND VPWR VPWR sky130_fd_sc_hd__decap_3
XFILLER_87_241 VGND VGND VPWR VPWR sky130_fd_sc_hd__decap_3
XFILLER_102_585 VGND VGND VPWR VPWR sky130_fd_sc_hd__decap_3
XFILLER_75_436 VGND VGND VPWR VPWR sky130_fd_sc_hd__decap_3
XFILLER_87_296 VGND VGND VPWR VPWR sky130_fd_sc_hd__decap_3
XTAP_TAPCELL_ROW_89_1315 VGND VPWR sky130_fd_sc_hd__tapvpwrvgnd_1
XFILLER_18_41 VGND VGND VPWR VPWR sky130_fd_sc_hd__decap_3
XFILLER_18_52 VGND VGND VPWR VPWR sky130_fd_sc_hd__decap_3
XFILLER_28_330 VGND VGND VPWR VPWR sky130_fd_sc_hd__decap_3
XFILLER_47_138 VGND VGND VPWR VPWR sky130_fd_sc_hd__decap_3
XFILLER_75_458 VGND VGND VPWR VPWR sky130_fd_sc_hd__decap_3
XFILLER_85_69 VGND VGND VPWR VPWR sky130_fd_sc_hd__decap_3
XTAP_TAPCELL_ROW_46_807 VGND VPWR sky130_fd_sc_hd__tapvpwrvgnd_1
XFILLER_18_85 VGND VGND VPWR VPWR sky130_fd_sc_hd__decap_3
XFILLER_55_160 VGND VGND VPWR VPWR sky130_fd_sc_hd__decap_3
XFILLER_62_108 VGND VGND VPWR VPWR sky130_fd_sc_hd__decap_3
XFILLER_16_536 VGND VGND VPWR VPWR sky130_fd_sc_hd__fill_1
XFILLER_43_311 VGND VGND VPWR VPWR sky130_fd_sc_hd__decap_3
XFILLER_43_333 VGND VGND VPWR VPWR sky130_fd_sc_hd__decap_3
XFILLER_71_620 VGND VGND VPWR VPWR sky130_fd_sc_hd__decap_3
XFILLER_71_653 VGND VGND VPWR VPWR sky130_fd_sc_hd__decap_3
XFILLER_43_377 VGND VGND VPWR VPWR sky130_fd_sc_hd__decap_3
XFILLER_70_141 VGND VGND VPWR VPWR sky130_fd_sc_hd__decap_3
XFILLER_70_163 VGND VGND VPWR VPWR sky130_fd_sc_hd__decap_3
XTAP_TAPCELL_ROW_26_564 VGND VPWR sky130_fd_sc_hd__tapvpwrvgnd_1
XFILLER_31_539 VGND VGND VPWR VPWR sky130_fd_sc_hd__fill_2
XTAP_TAPCELL_ROW_54_895 VGND VPWR sky130_fd_sc_hd__tapvpwrvgnd_1
XFILLER_11_252 VGND VGND VPWR VPWR sky130_fd_sc_hd__decap_3
XFILLER_7_223 VGND VGND VPWR VPWR sky130_fd_sc_hd__fill_1
XFILLER_11_296 VGND VGND VPWR VPWR sky130_fd_sc_hd__decap_3
XFILLER_7_234 VGND VGND VPWR VPWR sky130_fd_sc_hd__fill_1
XFILLER_7_256 VGND VGND VPWR VPWR sky130_fd_sc_hd__decap_3
XFILLER_50_61 VGND VGND VPWR VPWR sky130_fd_sc_hd__decap_3
XFILLER_50_94 VGND VGND VPWR VPWR sky130_fd_sc_hd__decap_3
XFILLER_112_305 VGND VGND VPWR VPWR sky130_fd_sc_hd__decap_3
XFILLER_98_539 VGND VGND VPWR VPWR sky130_fd_sc_hd__decap_3
XFILLER_98_528 VGND VGND VPWR VPWR sky130_fd_sc_hd__decap_3
XFILLER_112_338 VGND VGND VPWR VPWR sky130_fd_sc_hd__decap_3
XFILLER_22_6 VGND VGND VPWR VPWR sky130_fd_sc_hd__decap_3
XFILLER_38_127 VGND VGND VPWR VPWR sky130_fd_sc_hd__decap_3
XFILLER_66_436 VGND VGND VPWR VPWR sky130_fd_sc_hd__decap_3
XFILLER_53_108 VGND VGND VPWR VPWR sky130_fd_sc_hd__decap_3
XFILLER_53_119 VGND VGND VPWR VPWR sky130_fd_sc_hd__fill_1
XFILLER_75_80 VGND VGND VPWR VPWR sky130_fd_sc_hd__decap_3
XTAP_TAPCELL_ROW_109_1562 VGND VPWR sky130_fd_sc_hd__tapvpwrvgnd_1
XFILLER_19_396 VGND VGND VPWR VPWR sky130_fd_sc_hd__decap_3
XFILLER_46_182 VGND VGND VPWR VPWR sky130_fd_sc_hd__decap_3
XFILLER_74_480 VGND VGND VPWR VPWR sky130_fd_sc_hd__fill_2
XFILLER_61_152 VGND VGND VPWR VPWR sky130_fd_sc_hd__decap_3
XFILLER_61_196 VGND VGND VPWR VPWR sky130_fd_sc_hd__decap_3
X_4712_ _7007_/Q _4738_/A VGND VGND VPWR VPWR _4731_/B sky130_fd_sc_hd__nand2_2
X_4643_ _4888_/A _4125_/X _4126_/A VGND VGND VPWR VPWR _4643_/Y sky130_fd_sc_hd__a21oi_2
X_7362_ _7362_/CLK _7362_/D _6642_/Y VGND VGND VPWR VPWR _7362_/Q sky130_fd_sc_hd__dfrtp_2
Xhold702 _6877_/Q VGND VGND VPWR VPWR _6877_/D sky130_fd_sc_hd__dlygate4sd3_1
X_7293_ _7360_/CLK _7293_/D _6573_/Y VGND VGND VPWR VPWR _7293_/Q sky130_fd_sc_hd__dfrtp_2
Xhold713 _6968_/Q VGND VGND VPWR VPWR _6968_/D sky130_fd_sc_hd__dlygate4sd3_1
Xhold724 _6746_/Q VGND VGND VPWR VPWR _6746_/D sky130_fd_sc_hd__dlygate4sd3_1
Xhold735 _6888_/Q VGND VGND VPWR VPWR _6888_/D sky130_fd_sc_hd__dlygate4sd3_1
Xhold746 _6751_/Q VGND VGND VPWR VPWR _6751_/D sky130_fd_sc_hd__dlygate4sd3_1
X_6313_ _6660_/A VGND VGND VPWR VPWR _6313_/Y sky130_fd_sc_hd__inv_2
X_3525_ _3525_/A _3525_/B VGND VGND VPWR VPWR _3604_/B sky130_fd_sc_hd__and2_2
XFILLER_103_305 VGND VGND VPWR VPWR sky130_fd_sc_hd__decap_3
Xhold757 _6813_/Q VGND VGND VPWR VPWR _6813_/D sky130_fd_sc_hd__dlygate4sd3_1
Xhold768 _6938_/Q VGND VGND VPWR VPWR _6938_/D sky130_fd_sc_hd__dlygate4sd3_1
Xhold779 _6797_/Q VGND VGND VPWR VPWR _6797_/D sky130_fd_sc_hd__dlygate4sd3_1
XTAP_TAPCELL_ROW_73_1127 VGND VPWR sky130_fd_sc_hd__tapvpwrvgnd_1
XFILLER_103_349 VGND VGND VPWR VPWR sky130_fd_sc_hd__decap_3
X_3456_ _7011_/Q _4601_/S _3448_/X _3455_/X VGND VGND VPWR VPWR _3456_/X sky130_fd_sc_hd__a211o_2
XFILLER_69_252 VGND VGND VPWR VPWR sky130_fd_sc_hd__decap_3
X_3387_ _3385_/Y _3386_/Y _3399_/A _3399_/B VGND VGND VPWR VPWR _3429_/B sky130_fd_sc_hd__a211o_2
XFILLER_111_382 VGND VGND VPWR VPWR sky130_fd_sc_hd__decap_3
XFILLER_29_105 VGND VGND VPWR VPWR sky130_fd_sc_hd__decap_3
XFILLER_29_116 VGND VGND VPWR VPWR sky130_fd_sc_hd__decap_3
XFILLER_57_414 VGND VGND VPWR VPWR sky130_fd_sc_hd__decap_3
XFILLER_69_296 VGND VGND VPWR VPWR sky130_fd_sc_hd__decap_3
X_5126_ _5126_/A0 _5125_/Y _5132_/S VGND VGND VPWR VPWR _7253_/D sky130_fd_sc_hd__mux2_2
XFILLER_111_393 VGND VGND VPWR VPWR sky130_fd_sc_hd__decap_3
XFILLER_29_149 VGND VGND VPWR VPWR sky130_fd_sc_hd__decap_3
XFILLER_57_458 VGND VGND VPWR VPWR sky130_fd_sc_hd__decap_3
XFILLER_84_222 VGND VGND VPWR VPWR sky130_fd_sc_hd__decap_3
X_5057_ _5057_/A _5057_/B VGND VGND VPWR VPWR _5057_/Y sky130_fd_sc_hd__nor2_2
XFILLER_55_28 VGND VGND VPWR VPWR sky130_fd_sc_hd__decap_3
XFILLER_84_288 VGND VGND VPWR VPWR sky130_fd_sc_hd__decap_3
XFILLER_25_311 VGND VGND VPWR VPWR sky130_fd_sc_hd__decap_3
XFILLER_37_193 VGND VGND VPWR VPWR sky130_fd_sc_hd__fill_2
XFILLER_72_439 VGND VGND VPWR VPWR sky130_fd_sc_hd__decap_3
XFILLER_111_34 VGND VGND VPWR VPWR sky130_fd_sc_hd__decap_3
XFILLER_25_355 VGND VGND VPWR VPWR sky130_fd_sc_hd__decap_3
XFILLER_52_141 VGND VGND VPWR VPWR sky130_fd_sc_hd__decap_3
XTAP_TAPCELL_ROW_84_1256 VGND VPWR sky130_fd_sc_hd__tapvpwrvgnd_1
XFILLER_111_78 VGND VGND VPWR VPWR sky130_fd_sc_hd__decap_3
XFILLER_25_388 VGND VGND VPWR VPWR sky130_fd_sc_hd__decap_3
XFILLER_40_303 VGND VGND VPWR VPWR sky130_fd_sc_hd__decap_3
XFILLER_52_174 VGND VGND VPWR VPWR sky130_fd_sc_hd__decap_3
XFILLER_71_16 VGND VGND VPWR VPWR sky130_fd_sc_hd__decap_3
XFILLER_80_483 VGND VGND VPWR VPWR sky130_fd_sc_hd__decap_3
XTAP_TAPCELL_ROW_23_523 VGND VPWR sky130_fd_sc_hd__tapvpwrvgnd_1
XFILLER_40_336 VGND VGND VPWR VPWR sky130_fd_sc_hd__decap_3
XTAP_TAPCELL_ROW_51_865 VGND VPWR sky130_fd_sc_hd__tapvpwrvgnd_1
XFILLER_107_611 VGND VGND VPWR VPWR sky130_fd_sc_hd__decap_3
XFILLER_105_3 VGND VGND VPWR VPWR sky130_fd_sc_hd__decap_3
XFILLER_106_110 VGND VGND VPWR VPWR sky130_fd_sc_hd__decap_3
XFILLER_20_20 VGND VGND VPWR VPWR sky130_fd_sc_hd__decap_3
XFILLER_20_53 VGND VGND VPWR VPWR sky130_fd_sc_hd__decap_3
XTAP_TAPCELL_ROW_95_1396 VGND VPWR sky130_fd_sc_hd__tapvpwrvgnd_1
XFILLER_0_410 VGND VGND VPWR VPWR sky130_fd_sc_hd__decap_3
XFILLER_0_421 VGND VGND VPWR VPWR sky130_fd_sc_hd__decap_3
XFILLER_96_68 VGND VGND VPWR VPWR sky130_fd_sc_hd__decap_3
XFILLER_102_360 VGND VGND VPWR VPWR sky130_fd_sc_hd__decap_3
XFILLER_48_403 VGND VGND VPWR VPWR sky130_fd_sc_hd__decap_3
XFILLER_48_436 VGND VGND VPWR VPWR sky130_fd_sc_hd__decap_3
XPHY_EDGE_ROW_42_Left_159 VGND VGND VPWR VPWR sky130_fd_sc_hd__decap_3
XFILLER_102_393 VGND VGND VPWR VPWR sky130_fd_sc_hd__decap_3
XFILLER_29_84 VGND VGND VPWR VPWR sky130_fd_sc_hd__decap_3
XFILLER_75_222 VGND VGND VPWR VPWR sky130_fd_sc_hd__fill_2
XFILLER_75_255 VGND VGND VPWR VPWR sky130_fd_sc_hd__decap_3
XTAP_TAPCELL_ROW_59_965 VGND VPWR sky130_fd_sc_hd__tapvpwrvgnd_1
XTAP_TAPCELL_ROW_59_954 VGND VPWR sky130_fd_sc_hd__tapvpwrvgnd_1
XFILLER_35_119 VGND VGND VPWR VPWR sky130_fd_sc_hd__fill_1
XFILLER_63_417 VGND VGND VPWR VPWR sky130_fd_sc_hd__decap_3
XFILLER_75_266 VGND VGND VPWR VPWR sky130_fd_sc_hd__decap_3
XFILLER_16_322 VGND VGND VPWR VPWR sky130_fd_sc_hd__decap_3
XFILLER_56_480 VGND VGND VPWR VPWR sky130_fd_sc_hd__decap_3
XFILLER_90_225 VGND VGND VPWR VPWR sky130_fd_sc_hd__decap_3
Xplace406 _4532_/S VGND VGND VPWR VPWR _4530_/S sky130_fd_sc_hd__buf_2
Xplace417 _3380_/Y VGND VGND VPWR VPWR _4419_/B1 sky130_fd_sc_hd__buf_2
Xplace428 _4414_/B1 VGND VGND VPWR VPWR _3968_/S sky130_fd_sc_hd__buf_2
XTAP_TAPCELL_ROW_3_292 VGND VPWR sky130_fd_sc_hd__tapvpwrvgnd_1
XFILLER_71_461 VGND VGND VPWR VPWR sky130_fd_sc_hd__fill_1
Xplace439 _3344_/Y VGND VGND VPWR VPWR _4677_/B sky130_fd_sc_hd__buf_2
XFILLER_16_399 VGND VGND VPWR VPWR sky130_fd_sc_hd__decap_3
XFILLER_31_314 VGND VGND VPWR VPWR sky130_fd_sc_hd__fill_1
XFILLER_43_163 VGND VGND VPWR VPWR sky130_fd_sc_hd__decap_3
XFILLER_45_94 VGND VGND VPWR VPWR sky130_fd_sc_hd__fill_1
XFILLER_71_472 VGND VGND VPWR VPWR sky130_fd_sc_hd__decap_3
XFILLER_43_196 VGND VGND VPWR VPWR sky130_fd_sc_hd__decap_3
XPHY_EDGE_ROW_51_Left_168 VGND VGND VPWR VPWR sky130_fd_sc_hd__decap_3
XFILLER_61_60 VGND VGND VPWR VPWR sky130_fd_sc_hd__decap_3
XFILLER_8_510 VGND VGND VPWR VPWR sky130_fd_sc_hd__fill_1
XFILLER_12_583 VGND VGND VPWR VPWR sky130_fd_sc_hd__decap_3
XANTENNA_4 _5642_/B VGND VGND VPWR VPWR sky130_fd_sc_hd__diode_2
X_3310_ _5118_/C _3519_/B _3383_/B _3386_/A VGND VGND VPWR VPWR _3310_/Y sky130_fd_sc_hd__a31oi_2
XFILLER_3_270 VGND VGND VPWR VPWR sky130_fd_sc_hd__decap_3
XFILLER_3_281 VGND VGND VPWR VPWR sky130_fd_sc_hd__decap_3
X_4290_ _4283_/X _4288_/X _5647_/B _4649_/A VGND VGND VPWR VPWR _4612_/B sky130_fd_sc_hd__a2bb2o_4
XFILLER_79_561 VGND VGND VPWR VPWR sky130_fd_sc_hd__decap_3
XPHY_EDGE_ROW_60_Left_177 VGND VGND VPWR VPWR sky130_fd_sc_hd__decap_3
XFILLER_98_358 VGND VGND VPWR VPWR sky130_fd_sc_hd__decap_3
XFILLER_20_3 VGND VGND VPWR VPWR sky130_fd_sc_hd__decap_3
XFILLER_39_414 VGND VGND VPWR VPWR sky130_fd_sc_hd__decap_3
XFILLER_66_200 VGND VGND VPWR VPWR sky130_fd_sc_hd__fill_2
XFILLER_39_436 VGND VGND VPWR VPWR sky130_fd_sc_hd__decap_3
XFILLER_66_233 VGND VGND VPWR VPWR sky130_fd_sc_hd__decap_3
XFILLER_94_542 VGND VGND VPWR VPWR sky130_fd_sc_hd__decap_3
XFILLER_54_406 VGND VGND VPWR VPWR sky130_fd_sc_hd__decap_3
XFILLER_94_597 VGND VGND VPWR VPWR sky130_fd_sc_hd__decap_3
XFILLER_35_620 VGND VGND VPWR VPWR sky130_fd_sc_hd__decap_3
XFILLER_81_214 VGND VGND VPWR VPWR sky130_fd_sc_hd__decap_3
X_6931_ _7198_/CLK _6931_/D VGND VGND VPWR VPWR _6931_/Q sky130_fd_sc_hd__dfxtp_2
XFILLER_34_152 VGND VGND VPWR VPWR sky130_fd_sc_hd__decap_3
X_6862_ _6968_/CLK _6862_/D VGND VGND VPWR VPWR _6862_/Q sky130_fd_sc_hd__dfxtp_2
XFILLER_34_185 VGND VGND VPWR VPWR sky130_fd_sc_hd__decap_3
XFILLER_62_472 VGND VGND VPWR VPWR sky130_fd_sc_hd__decap_3
XFILLER_62_483 VGND VGND VPWR VPWR sky130_fd_sc_hd__decap_3
XFILLER_22_336 VGND VGND VPWR VPWR sky130_fd_sc_hd__decap_3
XFILLER_50_645 VGND VGND VPWR VPWR sky130_fd_sc_hd__fill_2
X_6793_ _6929_/CLK _6793_/D VGND VGND VPWR VPWR _6793_/Q sky130_fd_sc_hd__dfxtp_2
XFILLER_30_380 VGND VGND VPWR VPWR sky130_fd_sc_hd__decap_3
XFILLER_108_419 VGND VGND VPWR VPWR sky130_fd_sc_hd__fill_1
X_4626_ _4256_/C _4626_/B _4626_/C VGND VGND VPWR VPWR _4626_/X sky130_fd_sc_hd__and3b_2
XFILLER_116_430 VGND VGND VPWR VPWR sky130_fd_sc_hd__decap_3
X_7345_ clkload3/A _7345_/D _6625_/Y VGND VGND VPWR VPWR _7345_/Q sky130_fd_sc_hd__dfrtp_2
XFILLER_104_603 VGND VGND VPWR VPWR sky130_fd_sc_hd__decap_3
XFILLER_116_452 VGND VGND VPWR VPWR sky130_fd_sc_hd__decap_3
XFILLER_103_113 VGND VGND VPWR VPWR sky130_fd_sc_hd__decap_3
XFILLER_104_625 VGND VGND VPWR VPWR sky130_fd_sc_hd__decap_3
XFILLER_116_496 VGND VGND VPWR VPWR sky130_fd_sc_hd__decap_3
XFILLER_89_314 VGND VGND VPWR VPWR sky130_fd_sc_hd__fill_1
XFILLER_89_325 VGND VGND VPWR VPWR sky130_fd_sc_hd__decap_3
X_7276_ _7340_/CLK _7276_/D _6556_/Y VGND VGND VPWR VPWR _7276_/Q sky130_fd_sc_hd__dfrtp_2
Xhold587 _6944_/Q VGND VGND VPWR VPWR _6944_/D sky130_fd_sc_hd__dlygate4sd3_1
X_4488_ _4488_/A0 _4554_/A _4488_/S VGND VGND VPWR VPWR _7335_/D sky130_fd_sc_hd__mux2_2
X_3508_ _3508_/A _3508_/B VGND VGND VPWR VPWR _3508_/Y sky130_fd_sc_hd__nor2_2
XFILLER_103_135 VGND VGND VPWR VPWR sky130_fd_sc_hd__decap_3
Xhold598 _6874_/Q VGND VGND VPWR VPWR _6874_/D sky130_fd_sc_hd__dlygate4sd3_1
X_3439_ _7282_/Q _4522_/S _4339_/B1 _7154_/Q _3438_/X VGND VGND VPWR VPWR _3439_/X
+ sky130_fd_sc_hd__a221o_2
XFILLER_57_222 VGND VGND VPWR VPWR sky130_fd_sc_hd__fill_2
XFILLER_66_38 VGND VGND VPWR VPWR sky130_fd_sc_hd__fill_1
XFILLER_97_391 VGND VGND VPWR VPWR sky130_fd_sc_hd__fill_1
Xhold1210 _7179_/Q VGND VGND VPWR VPWR _5302_/A0 sky130_fd_sc_hd__dlygate4sd3_1
XFILLER_45_417 VGND VGND VPWR VPWR sky130_fd_sc_hd__decap_3
XFILLER_57_255 VGND VGND VPWR VPWR sky130_fd_sc_hd__decap_3
XFILLER_72_203 VGND VGND VPWR VPWR sky130_fd_sc_hd__decap_3
XTAP_TAPCELL_ROW_56_924 VGND VPWR sky130_fd_sc_hd__tapvpwrvgnd_1
XFILLER_17_119 VGND VGND VPWR VPWR sky130_fd_sc_hd__decap_3
XFILLER_45_439 VGND VGND VPWR VPWR sky130_fd_sc_hd__decap_3
XFILLER_57_299 VGND VGND VPWR VPWR sky130_fd_sc_hd__decap_3
XFILLER_72_225 VGND VGND VPWR VPWR sky130_fd_sc_hd__decap_3
XFILLER_60_409 VGND VGND VPWR VPWR sky130_fd_sc_hd__decap_3
XTAP_TAPCELL_ROW_0_251 VGND VPWR sky130_fd_sc_hd__tapvpwrvgnd_1
XTAP_TAPCELL_ROW_0_240 VGND VPWR sky130_fd_sc_hd__tapvpwrvgnd_1
XFILLER_13_303 VGND VGND VPWR VPWR sky130_fd_sc_hd__decap_3
XTAP_TAPCELL_ROW_36_681 VGND VPWR sky130_fd_sc_hd__tapvpwrvgnd_1
XFILLER_25_196 VGND VGND VPWR VPWR sky130_fd_sc_hd__decap_3
XFILLER_40_133 VGND VGND VPWR VPWR sky130_fd_sc_hd__decap_3
XFILLER_40_144 VGND VGND VPWR VPWR sky130_fd_sc_hd__decap_3
XFILLER_80_280 VGND VGND VPWR VPWR sky130_fd_sc_hd__decap_3
XFILLER_13_369 VGND VGND VPWR VPWR sky130_fd_sc_hd__decap_3
XFILLER_15_86 VGND VGND VPWR VPWR sky130_fd_sc_hd__decap_3
XFILLER_15_97 VGND VGND VPWR VPWR sky130_fd_sc_hd__decap_3
XFILLER_40_177 VGND VGND VPWR VPWR sky130_fd_sc_hd__decap_3
XTAP_TAPCELL_ROW_97_1414 VGND VPWR sky130_fd_sc_hd__tapvpwrvgnd_1
XFILLER_5_502 VGND VGND VPWR VPWR sky130_fd_sc_hd__fill_2
XFILLER_31_74 VGND VGND VPWR VPWR sky130_fd_sc_hd__decap_3
XFILLER_107_452 VGND VGND VPWR VPWR sky130_fd_sc_hd__decap_3
XTAP_TAPCELL_ROW_8_351 VGND VPWR sky130_fd_sc_hd__tapvpwrvgnd_1
XFILLER_0_262 VGND VGND VPWR VPWR sky130_fd_sc_hd__fill_1
XFILLER_110_628 VGND VGND VPWR VPWR sky130_fd_sc_hd__decap_3
XFILLER_48_200 VGND VGND VPWR VPWR sky130_fd_sc_hd__decap_3
XFILLER_0_295 VGND VGND VPWR VPWR sky130_fd_sc_hd__decap_3
XFILLER_48_244 VGND VGND VPWR VPWR sky130_fd_sc_hd__decap_3
XFILLER_76_531 VGND VGND VPWR VPWR sky130_fd_sc_hd__fill_1
XFILLER_76_542 VGND VGND VPWR VPWR sky130_fd_sc_hd__decap_3
XFILLER_88_380 VGND VGND VPWR VPWR sky130_fd_sc_hd__decap_3
XFILLER_76_564 VGND VGND VPWR VPWR sky130_fd_sc_hd__decap_3
XFILLER_91_501 VGND VGND VPWR VPWR sky130_fd_sc_hd__decap_3
XFILLER_17_620 VGND VGND VPWR VPWR sky130_fd_sc_hd__fill_2
XFILLER_17_631 VGND VGND VPWR VPWR sky130_fd_sc_hd__fill_2
XFILLER_56_71 VGND VGND VPWR VPWR sky130_fd_sc_hd__decap_3
XFILLER_63_214 VGND VGND VPWR VPWR sky130_fd_sc_hd__fill_1
XFILLER_91_545 VGND VGND VPWR VPWR sky130_fd_sc_hd__decap_3
XTAP_TAPCELL_ROW_106_1521 VGND VPWR sky130_fd_sc_hd__tapvpwrvgnd_1
XFILLER_16_141 VGND VGND VPWR VPWR sky130_fd_sc_hd__decap_3
XFILLER_17_653 VGND VGND VPWR VPWR sky130_fd_sc_hd__decap_3
XFILLER_44_450 VGND VGND VPWR VPWR sky130_fd_sc_hd__decap_3
XFILLER_91_567 VGND VGND VPWR VPWR sky130_fd_sc_hd__decap_3
XFILLER_16_174 VGND VGND VPWR VPWR sky130_fd_sc_hd__decap_3
XFILLER_44_483 VGND VGND VPWR VPWR sky130_fd_sc_hd__decap_3
Xplace269 _3925_/B1 VGND VGND VPWR VPWR _3858_/B1 sky130_fd_sc_hd__buf_2
XFILLER_31_111 VGND VGND VPWR VPWR sky130_fd_sc_hd__fill_1
XFILLER_31_122 VGND VGND VPWR VPWR sky130_fd_sc_hd__decap_3
XFILLER_32_645 VGND VGND VPWR VPWR sky130_fd_sc_hd__fill_1
X_3790_ _3746_/X _3777_/X _3779_/X _3682_/A _3789_/X VGND VGND VPWR VPWR _3790_/X
+ sky130_fd_sc_hd__a221o_2
XFILLER_12_380 VGND VGND VPWR VPWR sky130_fd_sc_hd__decap_3
XFILLER_31_188 VGND VGND VPWR VPWR sky130_fd_sc_hd__decap_3
X_4411_ _4411_/A _4411_/B VGND VGND VPWR VPWR _4412_/B sky130_fd_sc_hd__and2_2
XFILLER_99_612 VGND VGND VPWR VPWR sky130_fd_sc_hd__decap_3
XFILLER_113_411 VGND VGND VPWR VPWR sky130_fd_sc_hd__decap_3
X_7130_ clkload6/A _7130_/D _6410_/Y VGND VGND VPWR VPWR _7130_/Q sky130_fd_sc_hd__dfrtp_2
X_4342_ _7063_/Q _4305_/B _4460_/A VGND VGND VPWR VPWR _4365_/B sky130_fd_sc_hd__o21a_2
XFILLER_99_623 VGND VGND VPWR VPWR sky130_fd_sc_hd__decap_3
XFILLER_113_444 VGND VGND VPWR VPWR sky130_fd_sc_hd__decap_3
XFILLER_113_455 VGND VGND VPWR VPWR sky130_fd_sc_hd__fill_2
X_7061_ clkload5/A _7061_/D _6341_/Y VGND VGND VPWR VPWR _7061_/Q sky130_fd_sc_hd__dfrtp_2
X_4273_ _4376_/A _4376_/B _4376_/C _4273_/D VGND VGND VPWR VPWR _4273_/Y sky130_fd_sc_hd__nor4_1
XFILLER_100_105 VGND VGND VPWR VPWR sky130_fd_sc_hd__decap_3
XFILLER_101_617 VGND VGND VPWR VPWR sky130_fd_sc_hd__decap_3
XFILLER_86_339 VGND VGND VPWR VPWR sky130_fd_sc_hd__decap_3
XFILLER_98_188 VGND VGND VPWR VPWR sky130_fd_sc_hd__decap_3
XFILLER_98_166 VGND VGND VPWR VPWR sky130_fd_sc_hd__decap_3
.ends
