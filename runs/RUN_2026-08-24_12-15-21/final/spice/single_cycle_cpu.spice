* NGSPICE file created from single_cycle_cpu.ext - technology: sky130A

* Black-box entry subcircuit for sky130_fd_sc_hd__fill_2 abstract view
.subckt sky130_fd_sc_hd__fill_2 VGND VNB VPB VPWR
.ends

* Black-box entry subcircuit for sky130_fd_sc_hd__decap_3 abstract view
.subckt sky130_fd_sc_hd__decap_3 VGND VNB VPB VPWR
.ends

* Black-box entry subcircuit for sky130_fd_sc_hd__fill_1 abstract view
.subckt sky130_fd_sc_hd__fill_1 VGND VNB VPB VPWR
.ends

* Black-box entry subcircuit for sky130_fd_sc_hd__dfxtp_2 abstract view
.subckt sky130_fd_sc_hd__dfxtp_2 CLK D VGND VNB VPB VPWR Q
.ends

* Black-box entry subcircuit for sky130_fd_sc_hd__tapvpwrvgnd_1 abstract view
.subckt sky130_fd_sc_hd__tapvpwrvgnd_1 VGND VPWR
.ends

* Black-box entry subcircuit for sky130_fd_sc_hd__mux2_2 abstract view
.subckt sky130_fd_sc_hd__mux2_2 A0 A1 S VGND VNB VPB VPWR X
.ends

* Black-box entry subcircuit for sky130_fd_sc_hd__nor4_2 abstract view
.subckt sky130_fd_sc_hd__nor4_2 A B C D VGND VNB VPB VPWR Y
.ends

* Black-box entry subcircuit for sky130_fd_sc_hd__or2_2 abstract view
.subckt sky130_fd_sc_hd__or2_2 A B VGND VNB VPB VPWR X
.ends

* Black-box entry subcircuit for sky130_fd_sc_hd__dfrtp_2 abstract view
.subckt sky130_fd_sc_hd__dfrtp_2 CLK D RESET_B VGND VNB VPB VPWR Q
.ends

* Black-box entry subcircuit for sky130_fd_sc_hd__dlygate4sd3_1 abstract view
.subckt sky130_fd_sc_hd__dlygate4sd3_1 A VGND VNB VPB VPWR X
.ends

* Black-box entry subcircuit for sky130_fd_sc_hd__nor3_2 abstract view
.subckt sky130_fd_sc_hd__nor3_2 A B C VGND VNB VPB VPWR Y
.ends

* Black-box entry subcircuit for sky130_fd_sc_hd__a221o_2 abstract view
.subckt sky130_fd_sc_hd__a221o_2 A1 A2 B1 B2 C1 VGND VNB VPB VPWR X
.ends

* Black-box entry subcircuit for sky130_fd_sc_hd__inv_2 abstract view
.subckt sky130_fd_sc_hd__inv_2 A VGND VNB VPB VPWR Y
.ends

* Black-box entry subcircuit for sky130_fd_sc_hd__a22o_2 abstract view
.subckt sky130_fd_sc_hd__a22o_2 A1 A2 B1 B2 VGND VNB VPB VPWR X
.ends

* Black-box entry subcircuit for sky130_fd_sc_hd__clkdlybuf4s25_1 abstract view
.subckt sky130_fd_sc_hd__clkdlybuf4s25_1 A VGND VNB VPB VPWR X
.ends

* Black-box entry subcircuit for sky130_fd_sc_hd__a211o_2 abstract view
.subckt sky130_fd_sc_hd__a211o_2 A1 A2 B1 C1 VGND VNB VPB VPWR X
.ends

* Black-box entry subcircuit for sky130_fd_sc_hd__and3_4 abstract view
.subckt sky130_fd_sc_hd__and3_4 A B C VGND VNB VPB VPWR X
.ends

* Black-box entry subcircuit for sky130_fd_sc_hd__a31o_2 abstract view
.subckt sky130_fd_sc_hd__a31o_2 A1 A2 A3 B1 VGND VNB VPB VPWR X
.ends

* Black-box entry subcircuit for sky130_fd_sc_hd__or4_4 abstract view
.subckt sky130_fd_sc_hd__or4_4 A B C D VGND VNB VPB VPWR X
.ends

* Black-box entry subcircuit for sky130_fd_sc_hd__nor2_2 abstract view
.subckt sky130_fd_sc_hd__nor2_2 A B VGND VNB VPB VPWR Y
.ends

* Black-box entry subcircuit for sky130_fd_sc_hd__o31a_2 abstract view
.subckt sky130_fd_sc_hd__o31a_2 A1 A2 A3 B1 VGND VNB VPB VPWR X
.ends

* Black-box entry subcircuit for sky130_fd_sc_hd__conb_1 abstract view
.subckt sky130_fd_sc_hd__conb_1 VGND VNB VPB VPWR HI LO
.ends

* Black-box entry subcircuit for sky130_fd_sc_hd__or3b_4 abstract view
.subckt sky130_fd_sc_hd__or3b_4 A B C_N VGND VNB VPB VPWR X
.ends

* Black-box entry subcircuit for sky130_fd_sc_hd__and2_2 abstract view
.subckt sky130_fd_sc_hd__and2_2 A B VGND VNB VPB VPWR X
.ends

* Black-box entry subcircuit for sky130_fd_sc_hd__xnor2_2 abstract view
.subckt sky130_fd_sc_hd__xnor2_2 A B VGND VNB VPB VPWR Y
.ends

* Black-box entry subcircuit for sky130_fd_sc_hd__o21ai_2 abstract view
.subckt sky130_fd_sc_hd__o21ai_2 A1 A2 B1 VGND VNB VPB VPWR Y
.ends

* Black-box entry subcircuit for sky130_fd_sc_hd__nand2_2 abstract view
.subckt sky130_fd_sc_hd__nand2_2 A B VGND VNB VPB VPWR Y
.ends

* Black-box entry subcircuit for sky130_fd_sc_hd__and3_2 abstract view
.subckt sky130_fd_sc_hd__and3_2 A B C VGND VNB VPB VPWR X
.ends

* Black-box entry subcircuit for sky130_fd_sc_hd__and2b_2 abstract view
.subckt sky130_fd_sc_hd__and2b_2 A_N B VGND VNB VPB VPWR X
.ends

* Black-box entry subcircuit for sky130_fd_sc_hd__a21o_2 abstract view
.subckt sky130_fd_sc_hd__a21o_2 A1 A2 B1 VGND VNB VPB VPWR X
.ends

* Black-box entry subcircuit for sky130_fd_sc_hd__or3_2 abstract view
.subckt sky130_fd_sc_hd__or3_2 A B C VGND VNB VPB VPWR X
.ends

* Black-box entry subcircuit for sky130_fd_sc_hd__buf_2 abstract view
.subckt sky130_fd_sc_hd__buf_2 A VGND VNB VPB VPWR X
.ends

* Black-box entry subcircuit for sky130_fd_sc_hd__diode_2 abstract view
.subckt sky130_fd_sc_hd__diode_2 DIODE VGND VNB VPB VPWR
.ends

* Black-box entry subcircuit for sky130_fd_sc_hd__a31oi_4 abstract view
.subckt sky130_fd_sc_hd__a31oi_4 A1 A2 A3 B1 VGND VNB VPB VPWR Y
.ends

* Black-box entry subcircuit for sky130_fd_sc_hd__o21a_2 abstract view
.subckt sky130_fd_sc_hd__o21a_2 A1 A2 B1 VGND VNB VPB VPWR X
.ends

* Black-box entry subcircuit for sky130_fd_sc_hd__o32a_2 abstract view
.subckt sky130_fd_sc_hd__o32a_2 A1 A2 A3 B1 B2 VGND VNB VPB VPWR X
.ends

* Black-box entry subcircuit for sky130_fd_sc_hd__or3b_2 abstract view
.subckt sky130_fd_sc_hd__or3b_2 A B C_N VGND VNB VPB VPWR X
.ends

* Black-box entry subcircuit for sky130_fd_sc_hd__clkbuf_16 abstract view
.subckt sky130_fd_sc_hd__clkbuf_16 A VGND VNB VPB VPWR X
.ends

* Black-box entry subcircuit for sky130_fd_sc_hd__o211ai_2 abstract view
.subckt sky130_fd_sc_hd__o211ai_2 A1 A2 B1 C1 VGND VNB VPB VPWR Y
.ends

* Black-box entry subcircuit for sky130_fd_sc_hd__o22a_2 abstract view
.subckt sky130_fd_sc_hd__o22a_2 A1 A2 B1 B2 VGND VNB VPB VPWR X
.ends

* Black-box entry subcircuit for sky130_fd_sc_hd__o221a_2 abstract view
.subckt sky130_fd_sc_hd__o221a_2 A1 A2 B1 B2 C1 VGND VNB VPB VPWR X
.ends

* Black-box entry subcircuit for sky130_fd_sc_hd__o311a_4 abstract view
.subckt sky130_fd_sc_hd__o311a_4 A1 A2 A3 B1 C1 VGND VNB VPB VPWR X
.ends

* Black-box entry subcircuit for sky130_fd_sc_hd__a211oi_4 abstract view
.subckt sky130_fd_sc_hd__a211oi_4 A1 A2 B1 C1 VGND VNB VPB VPWR Y
.ends

* Black-box entry subcircuit for sky130_fd_sc_hd__xor2_2 abstract view
.subckt sky130_fd_sc_hd__xor2_2 A B VGND VNB VPB VPWR X
.ends

* Black-box entry subcircuit for sky130_fd_sc_hd__or4b_2 abstract view
.subckt sky130_fd_sc_hd__or4b_2 A B C D_N VGND VNB VPB VPWR X
.ends

* Black-box entry subcircuit for sky130_fd_sc_hd__o2bb2a_2 abstract view
.subckt sky130_fd_sc_hd__o2bb2a_2 A1_N A2_N B1 B2 VGND VNB VPB VPWR X
.ends

* Black-box entry subcircuit for sky130_fd_sc_hd__nand3_2 abstract view
.subckt sky130_fd_sc_hd__nand3_2 A B C VGND VNB VPB VPWR Y
.ends

* Black-box entry subcircuit for sky130_fd_sc_hd__o31ai_4 abstract view
.subckt sky130_fd_sc_hd__o31ai_4 A1 A2 A3 B1 VGND VNB VPB VPWR Y
.ends

* Black-box entry subcircuit for sky130_fd_sc_hd__o21ba_2 abstract view
.subckt sky130_fd_sc_hd__o21ba_2 A1 A2 B1_N VGND VNB VPB VPWR X
.ends

* Black-box entry subcircuit for sky130_fd_sc_hd__or2_4 abstract view
.subckt sky130_fd_sc_hd__or2_4 A B VGND VNB VPB VPWR X
.ends

* Black-box entry subcircuit for sky130_fd_sc_hd__nor2_1 abstract view
.subckt sky130_fd_sc_hd__nor2_1 A B VGND VNB VPB VPWR Y
.ends

* Black-box entry subcircuit for sky130_fd_sc_hd__a211oi_2 abstract view
.subckt sky130_fd_sc_hd__a211oi_2 A1 A2 B1 C1 VGND VNB VPB VPWR Y
.ends

* Black-box entry subcircuit for sky130_fd_sc_hd__a21bo_2 abstract view
.subckt sky130_fd_sc_hd__a21bo_2 A1 A2 B1_N VGND VNB VPB VPWR X
.ends

* Black-box entry subcircuit for sky130_fd_sc_hd__a31oi_2 abstract view
.subckt sky130_fd_sc_hd__a31oi_2 A1 A2 A3 B1 VGND VNB VPB VPWR Y
.ends

* Black-box entry subcircuit for sky130_fd_sc_hd__a21oi_2 abstract view
.subckt sky130_fd_sc_hd__a21oi_2 A1 A2 B1 VGND VNB VPB VPWR Y
.ends

* Black-box entry subcircuit for sky130_fd_sc_hd__o211a_2 abstract view
.subckt sky130_fd_sc_hd__o211a_2 A1 A2 B1 C1 VGND VNB VPB VPWR X
.ends

* Black-box entry subcircuit for sky130_fd_sc_hd__or2b_2 abstract view
.subckt sky130_fd_sc_hd__or2b_2 A B_N VGND VNB VPB VPWR X
.ends

* Black-box entry subcircuit for sky130_fd_sc_hd__a32o_2 abstract view
.subckt sky130_fd_sc_hd__a32o_2 A1 A2 A3 B1 B2 VGND VNB VPB VPWR X
.ends

* Black-box entry subcircuit for sky130_fd_sc_hd__a2bb2o_2 abstract view
.subckt sky130_fd_sc_hd__a2bb2o_2 A1_N A2_N B1 B2 VGND VNB VPB VPWR X
.ends

* Black-box entry subcircuit for sky130_fd_sc_hd__xor2_4 abstract view
.subckt sky130_fd_sc_hd__xor2_4 A B VGND VNB VPB VPWR X
.ends

* Black-box entry subcircuit for sky130_fd_sc_hd__buf_1 abstract view
.subckt sky130_fd_sc_hd__buf_1 A VGND VNB VPB VPWR X
.ends

* Black-box entry subcircuit for sky130_fd_sc_hd__a21boi_2 abstract view
.subckt sky130_fd_sc_hd__a21boi_2 A1 A2 B1_N VGND VNB VPB VPWR Y
.ends

* Black-box entry subcircuit for sky130_fd_sc_hd__and2_4 abstract view
.subckt sky130_fd_sc_hd__and2_4 A B VGND VNB VPB VPWR X
.ends

* Black-box entry subcircuit for sky130_fd_sc_hd__o2111a_2 abstract view
.subckt sky130_fd_sc_hd__o2111a_2 A1 A2 B1 C1 D1 VGND VNB VPB VPWR X
.ends

* Black-box entry subcircuit for sky130_fd_sc_hd__and4_4 abstract view
.subckt sky130_fd_sc_hd__and4_4 A B C D VGND VNB VPB VPWR X
.ends

* Black-box entry subcircuit for sky130_fd_sc_hd__o31ai_2 abstract view
.subckt sky130_fd_sc_hd__o31ai_2 A1 A2 A3 B1 VGND VNB VPB VPWR Y
.ends

* Black-box entry subcircuit for sky130_fd_sc_hd__o311a_2 abstract view
.subckt sky130_fd_sc_hd__o311a_2 A1 A2 A3 B1 C1 VGND VNB VPB VPWR X
.ends

* Black-box entry subcircuit for sky130_fd_sc_hd__clkbuf_1 abstract view
.subckt sky130_fd_sc_hd__clkbuf_1 A VGND VNB VPB VPWR X
.ends

* Black-box entry subcircuit for sky130_fd_sc_hd__a31o_4 abstract view
.subckt sky130_fd_sc_hd__a31o_4 A1 A2 A3 B1 VGND VNB VPB VPWR X
.ends

* Black-box entry subcircuit for sky130_fd_sc_hd__bufinv_16 abstract view
.subckt sky130_fd_sc_hd__bufinv_16 A VGND VNB VPB VPWR Y
.ends

* Black-box entry subcircuit for sky130_fd_sc_hd__inv_4 abstract view
.subckt sky130_fd_sc_hd__inv_4 A VGND VNB VPB VPWR Y
.ends

* Black-box entry subcircuit for sky130_fd_sc_hd__nor2_4 abstract view
.subckt sky130_fd_sc_hd__nor2_4 A B VGND VNB VPB VPWR Y
.ends

* Black-box entry subcircuit for sky130_fd_sc_hd__clkbuf_8 abstract view
.subckt sky130_fd_sc_hd__clkbuf_8 A VGND VNB VPB VPWR X
.ends

* Black-box entry subcircuit for sky130_fd_sc_hd__clkinv_2 abstract view
.subckt sky130_fd_sc_hd__clkinv_2 A VGND VNB VPB VPWR Y
.ends

* Black-box entry subcircuit for sky130_fd_sc_hd__clkinv_4 abstract view
.subckt sky130_fd_sc_hd__clkinv_4 A VGND VNB VPB VPWR Y
.ends

* Black-box entry subcircuit for sky130_fd_sc_hd__a221oi_2 abstract view
.subckt sky130_fd_sc_hd__a221oi_2 A1 A2 B1 B2 C1 VGND VNB VPB VPWR Y
.ends

* Black-box entry subcircuit for sky130_fd_sc_hd__and3b_2 abstract view
.subckt sky130_fd_sc_hd__and3b_2 A_N B C VGND VNB VPB VPWR X
.ends

* Black-box entry subcircuit for sky130_fd_sc_hd__nand3b_2 abstract view
.subckt sky130_fd_sc_hd__nand3b_2 A_N B C VGND VNB VPB VPWR Y
.ends

* Black-box entry subcircuit for sky130_fd_sc_hd__or3_4 abstract view
.subckt sky130_fd_sc_hd__or3_4 A B C VGND VNB VPB VPWR X
.ends

* Black-box entry subcircuit for sky130_fd_sc_hd__nor4b_2 abstract view
.subckt sky130_fd_sc_hd__nor4b_2 A B C D_N VGND VNB VPB VPWR Y
.ends

* Black-box entry subcircuit for sky130_fd_sc_hd__clkinv_8 abstract view
.subckt sky130_fd_sc_hd__clkinv_8 A VGND VNB VPB VPWR Y
.ends

* Black-box entry subcircuit for sky130_fd_sc_hd__a21oi_4 abstract view
.subckt sky130_fd_sc_hd__a21oi_4 A1 A2 B1 VGND VNB VPB VPWR Y
.ends

* Black-box entry subcircuit for sky130_fd_sc_hd__o221ai_2 abstract view
.subckt sky130_fd_sc_hd__o221ai_2 A1 A2 B1 B2 C1 VGND VNB VPB VPWR Y
.ends

* Black-box entry subcircuit for sky130_fd_sc_hd__nand2b_4 abstract view
.subckt sky130_fd_sc_hd__nand2b_4 A_N B VGND VNB VPB VPWR Y
.ends

* Black-box entry subcircuit for sky130_fd_sc_hd__a2111o_2 abstract view
.subckt sky130_fd_sc_hd__a2111o_2 A1 A2 B1 C1 D1 VGND VNB VPB VPWR X
.ends

* Black-box entry subcircuit for sky130_fd_sc_hd__mux4_2 abstract view
.subckt sky130_fd_sc_hd__mux4_2 A0 A1 A2 A3 S0 S1 VGND VNB VPB VPWR X
.ends

* Black-box entry subcircuit for sky130_fd_sc_hd__clkbuf_2 abstract view
.subckt sky130_fd_sc_hd__clkbuf_2 A VGND VNB VPB VPWR X
.ends

* Black-box entry subcircuit for sky130_fd_sc_hd__dfstp_2 abstract view
.subckt sky130_fd_sc_hd__dfstp_2 CLK D SET_B VGND VNB VPB VPWR Q
.ends

* Black-box entry subcircuit for sky130_fd_sc_hd__nor2b_2 abstract view
.subckt sky130_fd_sc_hd__nor2b_2 A B_N VGND VNB VPB VPWR Y
.ends

* Black-box entry subcircuit for sky130_fd_sc_hd__or4_2 abstract view
.subckt sky130_fd_sc_hd__or4_2 A B C D VGND VNB VPB VPWR X
.ends

* Black-box entry subcircuit for sky130_fd_sc_hd__and4_2 abstract view
.subckt sky130_fd_sc_hd__and4_2 A B C D VGND VNB VPB VPWR X
.ends

* Black-box entry subcircuit for sky130_fd_sc_hd__a311oi_2 abstract view
.subckt sky130_fd_sc_hd__a311oi_2 A1 A2 A3 B1 C1 VGND VNB VPB VPWR Y
.ends

* Black-box entry subcircuit for sky130_fd_sc_hd__o21a_4 abstract view
.subckt sky130_fd_sc_hd__o21a_4 A1 A2 B1 VGND VNB VPB VPWR X
.ends

* Black-box entry subcircuit for sky130_fd_sc_hd__nor4_1 abstract view
.subckt sky130_fd_sc_hd__nor4_1 A B C D VGND VNB VPB VPWR Y
.ends

* Black-box entry subcircuit for sky130_fd_sc_hd__a41o_2 abstract view
.subckt sky130_fd_sc_hd__a41o_2 A1 A2 A3 A4 B1 VGND VNB VPB VPWR X
.ends

* Black-box entry subcircuit for sky130_fd_sc_hd__nand4bb_2 abstract view
.subckt sky130_fd_sc_hd__nand4bb_2 A_N B_N C D VGND VNB VPB VPWR Y
.ends

* Black-box entry subcircuit for sky130_fd_sc_hd__o21bai_2 abstract view
.subckt sky130_fd_sc_hd__o21bai_2 A1 A2 B1_N VGND VNB VPB VPWR Y
.ends

* Black-box entry subcircuit for sky130_fd_sc_hd__nand2_4 abstract view
.subckt sky130_fd_sc_hd__nand2_4 A B VGND VNB VPB VPWR Y
.ends

* Black-box entry subcircuit for sky130_fd_sc_hd__mux2_4 abstract view
.subckt sky130_fd_sc_hd__mux2_4 A0 A1 S VGND VNB VPB VPWR X
.ends

* Black-box entry subcircuit for sky130_fd_sc_hd__o211ai_4 abstract view
.subckt sky130_fd_sc_hd__o211ai_4 A1 A2 B1 C1 VGND VNB VPB VPWR Y
.ends

* Black-box entry subcircuit for sky130_fd_sc_hd__and4bb_4 abstract view
.subckt sky130_fd_sc_hd__and4bb_4 A_N B_N C D VGND VNB VPB VPWR X
.ends

* Black-box entry subcircuit for sky130_fd_sc_hd__o21ai_4 abstract view
.subckt sky130_fd_sc_hd__o21ai_4 A1 A2 B1 VGND VNB VPB VPWR Y
.ends

* Black-box entry subcircuit for sky130_fd_sc_hd__o31ai_1 abstract view
.subckt sky130_fd_sc_hd__o31ai_1 A1 A2 A3 B1 VGND VNB VPB VPWR Y
.ends

* Black-box entry subcircuit for sky130_fd_sc_hd__nand2b_2 abstract view
.subckt sky130_fd_sc_hd__nand2b_2 A_N B VGND VNB VPB VPWR Y
.ends

* Black-box entry subcircuit for sky130_fd_sc_hd__o211a_4 abstract view
.subckt sky130_fd_sc_hd__o211a_4 A1 A2 B1 C1 VGND VNB VPB VPWR X
.ends

* Black-box entry subcircuit for sky130_fd_sc_hd__or4b_4 abstract view
.subckt sky130_fd_sc_hd__or4b_4 A B C D_N VGND VNB VPB VPWR X
.ends

* Black-box entry subcircuit for sky130_fd_sc_hd__inv_6 abstract view
.subckt sky130_fd_sc_hd__inv_6 A VGND VNB VPB VPWR Y
.ends

* Black-box entry subcircuit for sky130_fd_sc_hd__nor4bb_2 abstract view
.subckt sky130_fd_sc_hd__nor4bb_2 A B C_N D_N VGND VNB VPB VPWR Y
.ends

* Black-box entry subcircuit for sky130_fd_sc_hd__and4b_4 abstract view
.subckt sky130_fd_sc_hd__and4b_4 A_N B C D VGND VNB VPB VPWR X
.ends

* Black-box entry subcircuit for sky130_fd_sc_hd__nor3b_2 abstract view
.subckt sky130_fd_sc_hd__nor3b_2 A B C_N VGND VNB VPB VPWR Y
.ends

* Black-box entry subcircuit for sky130_fd_sc_hd__a22oi_2 abstract view
.subckt sky130_fd_sc_hd__a22oi_2 A1 A2 B1 B2 VGND VNB VPB VPWR Y
.ends

* Black-box entry subcircuit for sky130_fd_sc_hd__clkbuf_4 abstract view
.subckt sky130_fd_sc_hd__clkbuf_4 A VGND VNB VPB VPWR X
.ends

* Black-box entry subcircuit for sky130_fd_sc_hd__a311o_2 abstract view
.subckt sky130_fd_sc_hd__a311o_2 A1 A2 A3 B1 C1 VGND VNB VPB VPWR X
.ends

* Black-box entry subcircuit for sky130_fd_sc_hd__nand4b_4 abstract view
.subckt sky130_fd_sc_hd__nand4b_4 A_N B C D VGND VNB VPB VPWR Y
.ends

* Black-box entry subcircuit for sky130_fd_sc_hd__a2bb2o_4 abstract view
.subckt sky130_fd_sc_hd__a2bb2o_4 A1_N A2_N B1 B2 VGND VNB VPB VPWR X
.ends

.subckt single_cycle_cpu VGND VPWR alu_result_out[0] alu_result_out[10] alu_result_out[11]
+ alu_result_out[12] alu_result_out[13] alu_result_out[14] alu_result_out[15] alu_result_out[16]
+ alu_result_out[17] alu_result_out[18] alu_result_out[19] alu_result_out[1] alu_result_out[20]
+ alu_result_out[21] alu_result_out[22] alu_result_out[23] alu_result_out[24] alu_result_out[25]
+ alu_result_out[26] alu_result_out[27] alu_result_out[28] alu_result_out[29] alu_result_out[2]
+ alu_result_out[30] alu_result_out[31] alu_result_out[3] alu_result_out[4] alu_result_out[5]
+ alu_result_out[6] alu_result_out[7] alu_result_out[8] alu_result_out[9] clk instruction_out[0]
+ instruction_out[10] instruction_out[11] instruction_out[12] instruction_out[13]
+ instruction_out[14] instruction_out[15] instruction_out[16] instruction_out[17]
+ instruction_out[18] instruction_out[19] instruction_out[1] instruction_out[20] instruction_out[21]
+ instruction_out[22] instruction_out[23] instruction_out[24] instruction_out[25]
+ instruction_out[26] instruction_out[27] instruction_out[28] instruction_out[29]
+ instruction_out[2] instruction_out[30] instruction_out[31] instruction_out[3] instruction_out[4]
+ instruction_out[5] instruction_out[6] instruction_out[7] instruction_out[8] instruction_out[9]
+ pc_out[0] pc_out[10] pc_out[11] pc_out[12] pc_out[13] pc_out[14] pc_out[15] pc_out[16]
+ pc_out[17] pc_out[18] pc_out[19] pc_out[1] pc_out[20] pc_out[21] pc_out[22] pc_out[23]
+ pc_out[24] pc_out[25] pc_out[26] pc_out[27] pc_out[28] pc_out[29] pc_out[2] pc_out[30]
+ pc_out[31] pc_out[3] pc_out[4] pc_out[5] pc_out[6] pc_out[7] pc_out[8] pc_out[9]
+ reset
XFILLER_100_138 VGND VGND VPWR VPWR sky130_fd_sc_hd__fill_2
XFILLER_39_244 VGND VGND VPWR VPWR sky130_fd_sc_hd__decap_3
XFILLER_67_531 VGND VGND VPWR VPWR sky130_fd_sc_hd__decap_3
XFILLER_54_203 VGND VGND VPWR VPWR sky130_fd_sc_hd__decap_3
XFILLER_67_575 VGND VGND VPWR VPWR sky130_fd_sc_hd__decap_3
XFILLER_27_439 VGND VGND VPWR VPWR sky130_fd_sc_hd__fill_1
XFILLER_39_299 VGND VGND VPWR VPWR sky130_fd_sc_hd__decap_3
XFILLER_54_236 VGND VGND VPWR VPWR sky130_fd_sc_hd__decap_3
XFILLER_67_597 VGND VGND VPWR VPWR sky130_fd_sc_hd__decap_3
X_6914_ _7383_/CLK _6914_/D VGND VGND VPWR VPWR _6914_/Q sky130_fd_sc_hd__dfxtp_2
XFILLER_35_461 VGND VGND VPWR VPWR sky130_fd_sc_hd__decap_3
XFILLER_35_472 VGND VGND VPWR VPWR sky130_fd_sc_hd__decap_3
XFILLER_82_589 VGND VGND VPWR VPWR sky130_fd_sc_hd__decap_3
XFILLER_23_634 VGND VGND VPWR VPWR sky130_fd_sc_hd__fill_2
XFILLER_35_494 VGND VGND VPWR VPWR sky130_fd_sc_hd__fill_1
XFILLER_62_280 VGND VGND VPWR VPWR sky130_fd_sc_hd__decap_3
X_6845_ _6975_/CLK _6845_/D VGND VGND VPWR VPWR _6845_/Q sky130_fd_sc_hd__dfxtp_2
XTAP_TAPCELL_ROW_81_1226 VGND VPWR sky130_fd_sc_hd__tapvpwrvgnd_1
XFILLER_22_144 VGND VGND VPWR VPWR sky130_fd_sc_hd__fill_1
XFILLER_22_166 VGND VGND VPWR VPWR sky130_fd_sc_hd__decap_3
X_6776_ _6976_/CLK _6776_/D VGND VGND VPWR VPWR _6776_/Q sky130_fd_sc_hd__dfxtp_2
XTAP_TAPCELL_ROW_61_982 VGND VPWR sky130_fd_sc_hd__tapvpwrvgnd_1
XTAP_TAPCELL_ROW_33_651 VGND VPWR sky130_fd_sc_hd__tapvpwrvgnd_1
X_5727_ _7369_/Q hold942/X _5737_/S VGND VGND VPWR VPWR _6713_/D sky130_fd_sc_hd__mux2_2
X_5658_ _5658_/A _5658_/B _5658_/C _5658_/D VGND VGND VPWR VPWR _5661_/C sky130_fd_sc_hd__nor4_2
XPHY_EDGE_ROW_107_Left_224 VGND VGND VPWR VPWR sky130_fd_sc_hd__decap_3
X_5589_ _5589_/A _5595_/B VGND VGND VPWR VPWR _7033_/D sky130_fd_sc_hd__or2_2
XTAP_TAPCELL_ROW_79_1199 VGND VPWR sky130_fd_sc_hd__tapvpwrvgnd_1
XFILLER_116_271 VGND VGND VPWR VPWR sky130_fd_sc_hd__decap_3
XFILLER_89_111 VGND VGND VPWR VPWR sky130_fd_sc_hd__fill_1
X_7328_ _7364_/CLK _7328_/D _6608_/Y VGND VGND VPWR VPWR _7328_/Q sky130_fd_sc_hd__dfrtp_2
XFILLER_77_15 VGND VGND VPWR VPWR sky130_fd_sc_hd__decap_3
X_7259_ clkload8/A _7259_/D _6539_/Y VGND VGND VPWR VPWR _7259_/Q sky130_fd_sc_hd__dfrtp_2
XTAP_TAPCELL_ROW_92_1355 VGND VPWR sky130_fd_sc_hd__tapvpwrvgnd_1
XFILLER_104_477 VGND VGND VPWR VPWR sky130_fd_sc_hd__decap_3
XTAP_TAPCELL_ROW_5_310 VGND VPWR sky130_fd_sc_hd__tapvpwrvgnd_1
XFILLER_100_672 VGND VGND VPWR VPWR sky130_fd_sc_hd__decap_3
XFILLER_58_575 VGND VGND VPWR VPWR sky130_fd_sc_hd__decap_3
Xhold1040 _7262_/Q VGND VGND VPWR VPWR _4998_/A0 sky130_fd_sc_hd__dlygate4sd3_1
Xhold1051 _7265_/Q VGND VGND VPWR VPWR _4946_/A0 sky130_fd_sc_hd__dlygate4sd3_1
XFILLER_45_203 VGND VGND VPWR VPWR sky130_fd_sc_hd__decap_3
XFILLER_45_225 VGND VGND VPWR VPWR sky130_fd_sc_hd__decap_3
XFILLER_73_512 VGND VGND VPWR VPWR sky130_fd_sc_hd__decap_3
XFILLER_73_545 VGND VGND VPWR VPWR sky130_fd_sc_hd__decap_3
XFILLER_85_383 VGND VGND VPWR VPWR sky130_fd_sc_hd__decap_3
Xhold1062 _7385_/Q VGND VGND VPWR VPWR _3864_/A0 sky130_fd_sc_hd__dlygate4sd3_1
Xhold1073 _7215_/Q VGND VGND VPWR VPWR _5227_/A1 sky130_fd_sc_hd__dlygate4sd3_1
Xhold1084 _7288_/Q VGND VGND VPWR VPWR _4585_/A sky130_fd_sc_hd__dlygate4sd3_1
XPHY_EDGE_ROW_116_Left_233 VGND VGND VPWR VPWR sky130_fd_sc_hd__decap_3
XFILLER_45_269 VGND VGND VPWR VPWR sky130_fd_sc_hd__decap_3
XFILLER_73_578 VGND VGND VPWR VPWR sky130_fd_sc_hd__decap_3
Xhold1095 _3931_/X VGND VGND VPWR VPWR _7374_/D sky130_fd_sc_hd__dlygate4sd3_1
XFILLER_26_461 VGND VGND VPWR VPWR sky130_fd_sc_hd__decap_3
XFILLER_26_63 VGND VGND VPWR VPWR sky130_fd_sc_hd__decap_3
XFILLER_14_645 VGND VGND VPWR VPWR sky130_fd_sc_hd__decap_3
XFILLER_26_85 VGND VGND VPWR VPWR sky130_fd_sc_hd__decap_3
XFILLER_60_239 VGND VGND VPWR VPWR sky130_fd_sc_hd__fill_1
XFILLER_41_475 VGND VGND VPWR VPWR sky130_fd_sc_hd__decap_3
XFILLER_13_199 VGND VGND VPWR VPWR sky130_fd_sc_hd__decap_3
XFILLER_42_40 VGND VGND VPWR VPWR sky130_fd_sc_hd__decap_3
XTAP_TAPCELL_ROW_101_1462 VGND VPWR sky130_fd_sc_hd__tapvpwrvgnd_1
XTAP_TAPCELL_ROW_11_389 VGND VPWR sky130_fd_sc_hd__tapvpwrvgnd_1
XTAP_TAPCELL_ROW_11_378 VGND VPWR sky130_fd_sc_hd__tapvpwrvgnd_1
XFILLER_54_9 VGND VGND VPWR VPWR sky130_fd_sc_hd__decap_3
XFILLER_5_387 VGND VGND VPWR VPWR sky130_fd_sc_hd__fill_1
XFILLER_107_293 VGND VGND VPWR VPWR sky130_fd_sc_hd__decap_3
XFILLER_3_12 VGND VGND VPWR VPWR sky130_fd_sc_hd__decap_3
XFILLER_3_45 VGND VGND VPWR VPWR sky130_fd_sc_hd__decap_3
XFILLER_96_626 VGND VGND VPWR VPWR sky130_fd_sc_hd__decap_3
XFILLER_1_582 VGND VGND VPWR VPWR sky130_fd_sc_hd__decap_3
XFILLER_3_78 VGND VGND VPWR VPWR sky130_fd_sc_hd__decap_3
XFILLER_96_648 VGND VGND VPWR VPWR sky130_fd_sc_hd__decap_3
XTAP_TAPCELL_ROW_112_1591 VGND VPWR sky130_fd_sc_hd__tapvpwrvgnd_1
XFILLER_49_575 VGND VGND VPWR VPWR sky130_fd_sc_hd__fill_2
XFILLER_76_350 VGND VGND VPWR VPWR sky130_fd_sc_hd__fill_2
XFILLER_76_361 VGND VGND VPWR VPWR sky130_fd_sc_hd__decap_3
XFILLER_95_169 VGND VGND VPWR VPWR sky130_fd_sc_hd__decap_3
XFILLER_36_203 VGND VGND VPWR VPWR sky130_fd_sc_hd__decap_3
XFILLER_49_597 VGND VGND VPWR VPWR sky130_fd_sc_hd__decap_3
XFILLER_36_236 VGND VGND VPWR VPWR sky130_fd_sc_hd__decap_3
XFILLER_51_206 VGND VGND VPWR VPWR sky130_fd_sc_hd__decap_3
XFILLER_64_589 VGND VGND VPWR VPWR sky130_fd_sc_hd__decap_3
X_4960_ _5587_/B _4960_/B _4960_/C VGND VGND VPWR VPWR _4961_/C sky130_fd_sc_hd__nor3_2
XTAP_TAPCELL_ROW_19_478 VGND VPWR sky130_fd_sc_hd__tapvpwrvgnd_1
X_4891_ _3526_/B _4126_/A _4889_/Y _4811_/C _4890_/Y VGND VGND VPWR VPWR _4891_/X
+ sky130_fd_sc_hd__a221o_2
X_3911_ _6690_/Q _3925_/A2 _3912_/B1 _6868_/Q _3910_/X VGND VGND VPWR VPWR _3911_/X
+ sky130_fd_sc_hd__a221o_2
XFILLER_32_453 VGND VGND VPWR VPWR sky130_fd_sc_hd__decap_3
X_6630_ _6635_/A VGND VGND VPWR VPWR _6630_/Y sky130_fd_sc_hd__inv_2
X_3842_ _6925_/Q _3886_/A2 _3886_/B1 _6789_/Q VGND VGND VPWR VPWR _3842_/X sky130_fd_sc_hd__a22o_2
XFILLER_20_637 VGND VGND VPWR VPWR sky130_fd_sc_hd__decap_3
X_6561_ _6562_/A VGND VGND VPWR VPWR _6561_/Y sky130_fd_sc_hd__inv_2
XTAP_TAPCELL_ROW_30_610 VGND VPWR sky130_fd_sc_hd__tapvpwrvgnd_1
X_3773_ _6775_/Q _3884_/A2 _3882_/A2 _6763_/Q VGND VGND VPWR VPWR _3773_/X sky130_fd_sc_hd__a22o_2
XFILLER_9_660 VGND VGND VPWR VPWR sky130_fd_sc_hd__decap_3
XFILLER_8_181 VGND VGND VPWR VPWR sky130_fd_sc_hd__decap_3
X_6492_ _6647_/A VGND VGND VPWR VPWR _6492_/Y sky130_fd_sc_hd__inv_2
XFILLER_9_682 VGND VGND VPWR VPWR sky130_fd_sc_hd__decap_3
X_7113_ _7337_/CLK _7113_/D _6393_/Y VGND VGND VPWR VPWR _7113_/Q sky130_fd_sc_hd__dfrtp_2
Xoutput478 _5655_/D VGND VGND VPWR VPWR alu_result_out[23] sky130_fd_sc_hd__clkdlybuf4s25_1
Xoutput467 _5023_/Y VGND VGND VPWR VPWR alu_result_out[13] sky130_fd_sc_hd__clkdlybuf4s25_1
X_4325_ _7354_/Q _4272_/B _4323_/X _4324_/X VGND VGND VPWR VPWR _4325_/X sky130_fd_sc_hd__a211o_2
XFILLER_113_252 VGND VGND VPWR VPWR sky130_fd_sc_hd__decap_3
XFILLER_59_306 VGND VGND VPWR VPWR sky130_fd_sc_hd__decap_3
XFILLER_86_103 VGND VGND VPWR VPWR sky130_fd_sc_hd__decap_3
XFILLER_87_615 VGND VGND VPWR VPWR sky130_fd_sc_hd__fill_1
XFILLER_87_626 VGND VGND VPWR VPWR sky130_fd_sc_hd__decap_3
Xoutput489 _3735_/A VGND VGND VPWR VPWR alu_result_out[4] sky130_fd_sc_hd__clkdlybuf4s25_1
XFILLER_99_486 VGND VGND VPWR VPWR sky130_fd_sc_hd__decap_3
XFILLER_101_447 VGND VGND VPWR VPWR sky130_fd_sc_hd__fill_1
XFILLER_47_18 VGND VGND VPWR VPWR sky130_fd_sc_hd__decap_3
XFILLER_86_125 VGND VGND VPWR VPWR sky130_fd_sc_hd__decap_3
XFILLER_87_659 VGND VGND VPWR VPWR sky130_fd_sc_hd__decap_3
X_7044_ _7398_/CLK _7044_/D _6324_/Y VGND VGND VPWR VPWR _7044_/Q sky130_fd_sc_hd__dfrtp_2
X_4256_ _4626_/B _4626_/C _4256_/C VGND VGND VPWR VPWR _4988_/A sky130_fd_sc_hd__and3_4
XFILLER_67_361 VGND VGND VPWR VPWR sky130_fd_sc_hd__fill_1
XFILLER_86_169 VGND VGND VPWR VPWR sky130_fd_sc_hd__decap_3
X_4187_ _7327_/Q _3962_/S _4505_/S _7295_/Q VGND VGND VPWR VPWR _4187_/X sky130_fd_sc_hd__a22o_2
XFILLER_103_24 VGND VGND VPWR VPWR sky130_fd_sc_hd__decap_3
XFILLER_27_225 VGND VGND VPWR VPWR sky130_fd_sc_hd__decap_3
XFILLER_55_523 VGND VGND VPWR VPWR sky130_fd_sc_hd__fill_1
XFILLER_67_383 VGND VGND VPWR VPWR sky130_fd_sc_hd__decap_3
XTAP_TAPCELL_ROW_38_710 VGND VPWR sky130_fd_sc_hd__tapvpwrvgnd_1
XFILLER_103_46 VGND VGND VPWR VPWR sky130_fd_sc_hd__decap_3
XFILLER_103_57 VGND VGND VPWR VPWR sky130_fd_sc_hd__fill_1
XFILLER_94_191 VGND VGND VPWR VPWR sky130_fd_sc_hd__decap_3
XFILLER_27_269 VGND VGND VPWR VPWR sky130_fd_sc_hd__fill_2
XFILLER_63_28 VGND VGND VPWR VPWR sky130_fd_sc_hd__decap_3
X_6828_ _6909_/CLK _6828_/D VGND VGND VPWR VPWR _6828_/Q sky130_fd_sc_hd__dfxtp_2
XFILLER_10_103 VGND VGND VPWR VPWR sky130_fd_sc_hd__decap_3
XFILLER_11_648 VGND VGND VPWR VPWR sky130_fd_sc_hd__decap_3
XFILLER_23_486 VGND VGND VPWR VPWR sky130_fd_sc_hd__decap_3
XFILLER_50_283 VGND VGND VPWR VPWR sky130_fd_sc_hd__decap_3
XFILLER_10_136 VGND VGND VPWR VPWR sky130_fd_sc_hd__decap_3
XFILLER_12_21 VGND VGND VPWR VPWR sky130_fd_sc_hd__decap_3
X_6759_ _6978_/CLK _6759_/D VGND VGND VPWR VPWR _6759_/Q sky130_fd_sc_hd__dfxtp_2
XFILLER_109_536 VGND VGND VPWR VPWR sky130_fd_sc_hd__decap_3
XFILLER_12_32 VGND VGND VPWR VPWR sky130_fd_sc_hd__decap_3
XFILLER_6_118 VGND VGND VPWR VPWR sky130_fd_sc_hd__decap_3
XFILLER_12_65 VGND VGND VPWR VPWR sky130_fd_sc_hd__decap_3
XFILLER_12_98 VGND VGND VPWR VPWR sky130_fd_sc_hd__decap_3
XFILLER_88_36 VGND VGND VPWR VPWR sky130_fd_sc_hd__decap_3
XFILLER_104_241 VGND VGND VPWR VPWR sky130_fd_sc_hd__decap_3
XFILLER_2_368 VGND VGND VPWR VPWR sky130_fd_sc_hd__decap_3
XFILLER_78_604 VGND VGND VPWR VPWR sky130_fd_sc_hd__decap_3
XFILLER_78_637 VGND VGND VPWR VPWR sky130_fd_sc_hd__decap_3
XFILLER_104_296 VGND VGND VPWR VPWR sky130_fd_sc_hd__decap_3
XFILLER_77_147 VGND VGND VPWR VPWR sky130_fd_sc_hd__decap_3
XFILLER_78_648 VGND VGND VPWR VPWR sky130_fd_sc_hd__decap_3
XFILLER_92_106 VGND VGND VPWR VPWR sky130_fd_sc_hd__decap_3
XFILLER_93_629 VGND VGND VPWR VPWR sky130_fd_sc_hd__decap_3
XFILLER_18_214 VGND VGND VPWR VPWR sky130_fd_sc_hd__decap_3
XFILLER_37_51 VGND VGND VPWR VPWR sky130_fd_sc_hd__decap_3
XFILLER_86_681 VGND VGND VPWR VPWR sky130_fd_sc_hd__decap_3
XFILLER_92_139 VGND VGND VPWR VPWR sky130_fd_sc_hd__fill_1
XFILLER_46_567 VGND VGND VPWR VPWR sky130_fd_sc_hd__decap_3
XFILLER_33_217 VGND VGND VPWR VPWR sky130_fd_sc_hd__decap_3
XFILLER_46_589 VGND VGND VPWR VPWR sky130_fd_sc_hd__decap_3
XFILLER_26_280 VGND VGND VPWR VPWR sky130_fd_sc_hd__decap_3
XFILLER_33_228 VGND VGND VPWR VPWR sky130_fd_sc_hd__decap_3
XFILLER_61_559 VGND VGND VPWR VPWR sky130_fd_sc_hd__fill_1
XTAP_TAPCELL_ROW_16_448 VGND VPWR sky130_fd_sc_hd__tapvpwrvgnd_1
XFILLER_14_442 VGND VGND VPWR VPWR sky130_fd_sc_hd__decap_3
XTAP_TAPCELL_ROW_44_779 VGND VPWR sky130_fd_sc_hd__tapvpwrvgnd_1
XFILLER_14_475 VGND VGND VPWR VPWR sky130_fd_sc_hd__fill_1
XFILLER_5_140 VGND VGND VPWR VPWR sky130_fd_sc_hd__decap_3
XFILLER_6_641 VGND VGND VPWR VPWR sky130_fd_sc_hd__decap_3
XFILLER_115_517 VGND VGND VPWR VPWR sky130_fd_sc_hd__decap_3
XFILLER_6_685 VGND VGND VPWR VPWR sky130_fd_sc_hd__decap_3
XTAP_TAPCELL_ROW_114_1620 VGND VPWR sky130_fd_sc_hd__tapvpwrvgnd_1
XFILLER_5_195 VGND VGND VPWR VPWR sky130_fd_sc_hd__fill_1
XFILLER_69_626 VGND VGND VPWR VPWR sky130_fd_sc_hd__decap_3
XFILLER_110_200 VGND VGND VPWR VPWR sky130_fd_sc_hd__decap_3
XFILLER_68_136 VGND VGND VPWR VPWR sky130_fd_sc_hd__decap_3
XFILLER_69_659 VGND VGND VPWR VPWR sky130_fd_sc_hd__decap_3
XFILLER_78_80 VGND VGND VPWR VPWR sky130_fd_sc_hd__decap_3
X_5090_ _5146_/B1 _5083_/X _5085_/X _5089_/Y VGND VGND VPWR VPWR _5658_/C sky130_fd_sc_hd__a31o_2
X_4110_ _4376_/A _4141_/A _4141_/B _4142_/C VGND VGND VPWR VPWR _4111_/B sky130_fd_sc_hd__or4_4
XFILLER_56_309 VGND VGND VPWR VPWR sky130_fd_sc_hd__decap_3
XFILLER_68_158 VGND VGND VPWR VPWR sky130_fd_sc_hd__decap_3
XFILLER_84_607 VGND VGND VPWR VPWR sky130_fd_sc_hd__decap_3
XFILLER_96_467 VGND VGND VPWR VPWR sky130_fd_sc_hd__decap_3
X_4041_ _7245_/Q _4430_/A2 _5229_/C _7149_/Q VGND VGND VPWR VPWR _4041_/X sky130_fd_sc_hd__a22o_2
XFILLER_110_277 VGND VGND VPWR VPWR sky130_fd_sc_hd__decap_3
XFILLER_37_534 VGND VGND VPWR VPWR sky130_fd_sc_hd__decap_3
XFILLER_83_128 VGND VGND VPWR VPWR sky130_fd_sc_hd__decap_3
XFILLER_92_651 VGND VGND VPWR VPWR sky130_fd_sc_hd__decap_3
XFILLER_91_172 VGND VGND VPWR VPWR sky130_fd_sc_hd__fill_1
XFILLER_92_684 VGND VGND VPWR VPWR sky130_fd_sc_hd__decap_3
XFILLER_24_239 VGND VGND VPWR VPWR sky130_fd_sc_hd__decap_3
X_4943_ _4943_/A _4943_/B VGND VGND VPWR VPWR _4944_/C sky130_fd_sc_hd__nor2_2
XTAP_TAPCELL_ROW_65_1029 VGND VPWR sky130_fd_sc_hd__tapvpwrvgnd_1
XFILLER_60_570 VGND VGND VPWR VPWR sky130_fd_sc_hd__decap_3
XFILLER_60_592 VGND VGND VPWR VPWR sky130_fd_sc_hd__decap_3
X_6613_ _6643_/A VGND VGND VPWR VPWR _6613_/Y sky130_fd_sc_hd__inv_2
X_4874_ _4814_/A _4849_/Y _4872_/X _4873_/X VGND VGND VPWR VPWR _4874_/X sky130_fd_sc_hd__o31a_2
X_3825_ _6749_/Q _3902_/A2 _3862_/B1 _6737_/Q VGND VGND VPWR VPWR _3825_/X sky130_fd_sc_hd__a22o_2
X_6544_ _6548_/A VGND VGND VPWR VPWR _6544_/Y sky130_fd_sc_hd__inv_2
X_3756_ _6798_/Q _3759_/A2 _3767_/A2 _6708_/Q _3755_/X VGND VGND VPWR VPWR _3756_/X
+ sky130_fd_sc_hd__a221o_2
X_6475_ _6535_/A VGND VGND VPWR VPWR _6475_/Y sky130_fd_sc_hd__inv_2
XFILLER_106_539 VGND VGND VPWR VPWR sky130_fd_sc_hd__decap_3
XTAP_TAPCELL_ROW_76_1158 VGND VPWR sky130_fd_sc_hd__tapvpwrvgnd_1
XTAP_TAPCELL_ROW_76_1169 VGND VPWR sky130_fd_sc_hd__tapvpwrvgnd_1
XFILLER_114_572 VGND VGND VPWR VPWR sky130_fd_sc_hd__decap_3
XFILLER_99_272 VGND VGND VPWR VPWR sky130_fd_sc_hd__decap_3
XFILLER_59_136 VGND VGND VPWR VPWR sky130_fd_sc_hd__fill_2
XFILLER_87_423 VGND VGND VPWR VPWR sky130_fd_sc_hd__decap_3
X_5288_ _5288_/A0 _3993_/X _5292_/S VGND VGND VPWR VPWR _7185_/D sky130_fd_sc_hd__mux2_2
X_4308_ _7192_/Q _3987_/S _4338_/B1 _7384_/Q VGND VGND VPWR VPWR _4308_/X sky130_fd_sc_hd__a22o_2
XFILLER_101_255 VGND VGND VPWR VPWR sky130_fd_sc_hd__decap_3
XFILLER_114_12 VGND VGND VPWR VPWR sky130_fd_sc_hd__decap_3
XFILLER_59_169 VGND VGND VPWR VPWR sky130_fd_sc_hd__decap_3
XFILLER_87_467 VGND VGND VPWR VPWR sky130_fd_sc_hd__decap_3
X_7027_ _7372_/CLK _7027_/D _6307_/Y VGND VGND VPWR VPWR _7027_/Q sky130_fd_sc_hd__dfrtp_2
X_4239_ _4628_/A _4629_/B VGND VGND VPWR VPWR _5018_/B sky130_fd_sc_hd__nor2_2
XFILLER_101_299 VGND VGND VPWR VPWR sky130_fd_sc_hd__decap_3
XFILLER_114_56 VGND VGND VPWR VPWR sky130_fd_sc_hd__decap_3
XFILLER_68_681 VGND VGND VPWR VPWR sky130_fd_sc_hd__decap_3
XFILLER_28_556 VGND VGND VPWR VPWR sky130_fd_sc_hd__decap_3
XFILLER_74_38 VGND VGND VPWR VPWR sky130_fd_sc_hd__decap_3
XFILLER_83_662 VGND VGND VPWR VPWR sky130_fd_sc_hd__decap_3
XFILLER_83_673 VGND VGND VPWR VPWR sky130_fd_sc_hd__decap_3
XFILLER_15_228 VGND VGND VPWR VPWR sky130_fd_sc_hd__decap_3
XFILLER_43_559 VGND VGND VPWR VPWR sky130_fd_sc_hd__fill_1
XFILLER_70_323 VGND VGND VPWR VPWR sky130_fd_sc_hd__fill_2
XTAP_TAPCELL_ROW_87_1298 VGND VPWR sky130_fd_sc_hd__tapvpwrvgnd_1
XFILLER_90_26 VGND VGND VPWR VPWR sky130_fd_sc_hd__fill_2
XFILLER_90_37 VGND VGND VPWR VPWR sky130_fd_sc_hd__decap_3
XFILLER_23_261 VGND VGND VPWR VPWR sky130_fd_sc_hd__decap_3
XFILLER_70_389 VGND VGND VPWR VPWR sky130_fd_sc_hd__fill_2
XTAP_TAPCELL_ROW_41_749 VGND VPWR sky130_fd_sc_hd__tapvpwrvgnd_1
XTAP_TAPCELL_ROW_41_738 VGND VPWR sky130_fd_sc_hd__tapvpwrvgnd_1
XTAP_TAPCELL_ROW_13_407 VGND VPWR sky130_fd_sc_hd__tapvpwrvgnd_1
XFILLER_23_42 VGND VGND VPWR VPWR sky130_fd_sc_hd__decap_3
XFILLER_23_75 VGND VGND VPWR VPWR sky130_fd_sc_hd__decap_3
XFILLER_7_449 VGND VGND VPWR VPWR sky130_fd_sc_hd__decap_3
XFILLER_109_399 VGND VGND VPWR VPWR sky130_fd_sc_hd__decap_3
XFILLER_3_611 VGND VGND VPWR VPWR sky130_fd_sc_hd__decap_3
XFILLER_99_57 VGND VGND VPWR VPWR sky130_fd_sc_hd__decap_3
XFILLER_2_121 VGND VGND VPWR VPWR sky130_fd_sc_hd__decap_3
XFILLER_3_655 VGND VGND VPWR VPWR sky130_fd_sc_hd__decap_3
XFILLER_105_561 VGND VGND VPWR VPWR sky130_fd_sc_hd__decap_3
XFILLER_78_401 VGND VGND VPWR VPWR sky130_fd_sc_hd__decap_3
XFILLER_2_187 VGND VGND VPWR VPWR sky130_fd_sc_hd__fill_1
XFILLER_66_607 VGND VGND VPWR VPWR sky130_fd_sc_hd__decap_3
XFILLER_17_9 VGND VGND VPWR VPWR sky130_fd_sc_hd__decap_3
XFILLER_48_72 VGND VGND VPWR VPWR sky130_fd_sc_hd__decap_3
XFILLER_65_128 VGND VGND VPWR VPWR sky130_fd_sc_hd__decap_3
Xsingle_cycle_cpu_579 VGND VGND VPWR VPWR single_cycle_cpu_579/HI instruction_out[29]
+ sky130_fd_sc_hd__conb_1
XTAP_TAPCELL_ROW_49_838 VGND VPWR sky130_fd_sc_hd__tapvpwrvgnd_1
XFILLER_0_35 VGND VGND VPWR VPWR sky130_fd_sc_hd__decap_3
XFILLER_19_556 VGND VGND VPWR VPWR sky130_fd_sc_hd__decap_3
XFILLER_58_191 VGND VGND VPWR VPWR sky130_fd_sc_hd__fill_1
XFILLER_74_651 VGND VGND VPWR VPWR sky130_fd_sc_hd__decap_3
XFILLER_0_68 VGND VGND VPWR VPWR sky130_fd_sc_hd__decap_3
XFILLER_19_578 VGND VGND VPWR VPWR sky130_fd_sc_hd__decap_3
XFILLER_74_684 VGND VGND VPWR VPWR sky130_fd_sc_hd__decap_3
XFILLER_46_397 VGND VGND VPWR VPWR sky130_fd_sc_hd__decap_3
XFILLER_61_334 VGND VGND VPWR VPWR sky130_fd_sc_hd__fill_2
XTAP_TAPCELL_ROW_29_595 VGND VPWR sky130_fd_sc_hd__tapvpwrvgnd_1
XFILLER_9_33 VGND VGND VPWR VPWR sky130_fd_sc_hd__decap_3
XFILLER_9_66 VGND VGND VPWR VPWR sky130_fd_sc_hd__decap_3
X_3610_ _3610_/A _3610_/B VGND VGND VPWR VPWR _3610_/Y sky130_fd_sc_hd__nor2_2
XPHY_EDGE_ROW_104_Right_104 VGND VGND VPWR VPWR sky130_fd_sc_hd__decap_3
XFILLER_9_99 VGND VGND VPWR VPWR sky130_fd_sc_hd__decap_3
X_3541_ _4376_/A _3541_/B _4460_/B VGND VGND VPWR VPWR _3541_/X sky130_fd_sc_hd__or3b_4
XFILLER_115_325 VGND VGND VPWR VPWR sky130_fd_sc_hd__decap_3
XFILLER_6_460 VGND VGND VPWR VPWR sky130_fd_sc_hd__decap_3
Xhold906 _7057_/Q VGND VGND VPWR VPWR _7057_/D sky130_fd_sc_hd__dlygate4sd3_1
Xhold917 _6701_/Q VGND VGND VPWR VPWR hold917/X sky130_fd_sc_hd__dlygate4sd3_1
Xhold928 _7025_/Q VGND VGND VPWR VPWR _5605_/A sky130_fd_sc_hd__dlygate4sd3_1
XFILLER_115_358 VGND VGND VPWR VPWR sky130_fd_sc_hd__decap_3
XFILLER_50_3 VGND VGND VPWR VPWR sky130_fd_sc_hd__decap_3
Xhold939 _7311_/Q VGND VGND VPWR VPWR hold939/X sky130_fd_sc_hd__dlygate4sd3_1
X_6260_ _6385_/A VGND VGND VPWR VPWR _6260_/Y sky130_fd_sc_hd__inv_2
X_3472_ _7216_/Q _4262_/A2 _4303_/B1 _7120_/Q VGND VGND VPWR VPWR _3472_/X sky130_fd_sc_hd__a22o_2
X_5211_ _5211_/A _5225_/B VGND VGND VPWR VPWR _7223_/D sky130_fd_sc_hd__and2_2
X_5142_ _5142_/A0 _3993_/X _5157_/S VGND VGND VPWR VPWR _7249_/D sky130_fd_sc_hd__mux2_2
XFILLER_111_542 VGND VGND VPWR VPWR sky130_fd_sc_hd__decap_3
XFILLER_111_564 VGND VGND VPWR VPWR sky130_fd_sc_hd__decap_3
XFILLER_69_478 VGND VGND VPWR VPWR sky130_fd_sc_hd__decap_3
XFILLER_111_597 VGND VGND VPWR VPWR sky130_fd_sc_hd__decap_3
XFILLER_56_128 VGND VGND VPWR VPWR sky130_fd_sc_hd__decap_3
XFILLER_57_629 VGND VGND VPWR VPWR sky130_fd_sc_hd__decap_3
XFILLER_84_415 VGND VGND VPWR VPWR sky130_fd_sc_hd__decap_3
XFILLER_96_275 VGND VGND VPWR VPWR sky130_fd_sc_hd__decap_3
XFILLER_96_297 VGND VGND VPWR VPWR sky130_fd_sc_hd__decap_3
X_5073_ _5073_/A _5073_/B VGND VGND VPWR VPWR _5073_/Y sky130_fd_sc_hd__xnor2_2
XTAP_TAPCELL_ROW_71_1099 VGND VPWR sky130_fd_sc_hd__tapvpwrvgnd_1
XFILLER_37_331 VGND VGND VPWR VPWR sky130_fd_sc_hd__fill_2
XFILLER_84_448 VGND VGND VPWR VPWR sky130_fd_sc_hd__decap_3
XFILLER_52_301 VGND VGND VPWR VPWR sky130_fd_sc_hd__decap_3
XFILLER_64_150 VGND VGND VPWR VPWR sky130_fd_sc_hd__decap_3
XFILLER_65_662 VGND VGND VPWR VPWR sky130_fd_sc_hd__decap_3
XFILLER_65_673 VGND VGND VPWR VPWR sky130_fd_sc_hd__decap_3
XFILLER_71_109 VGND VGND VPWR VPWR sky130_fd_sc_hd__decap_3
XFILLER_25_559 VGND VGND VPWR VPWR sky130_fd_sc_hd__fill_1
XFILLER_52_312 VGND VGND VPWR VPWR sky130_fd_sc_hd__decap_3
XFILLER_80_621 VGND VGND VPWR VPWR sky130_fd_sc_hd__decap_3
XFILLER_12_209 VGND VGND VPWR VPWR sky130_fd_sc_hd__decap_3
XFILLER_52_345 VGND VGND VPWR VPWR sky130_fd_sc_hd__fill_2
XFILLER_52_356 VGND VGND VPWR VPWR sky130_fd_sc_hd__decap_3
XFILLER_80_654 VGND VGND VPWR VPWR sky130_fd_sc_hd__decap_3
XFILLER_80_687 VGND VGND VPWR VPWR sky130_fd_sc_hd__decap_3
XFILLER_100_25 VGND VGND VPWR VPWR sky130_fd_sc_hd__decap_3
X_4926_ _4948_/A _4920_/Y _4925_/X VGND VGND VPWR VPWR _5656_/C sky130_fd_sc_hd__o21ai_2
XFILLER_100_69 VGND VGND VPWR VPWR sky130_fd_sc_hd__decap_3
XFILLER_20_220 VGND VGND VPWR VPWR sky130_fd_sc_hd__decap_3
XFILLER_60_18 VGND VGND VPWR VPWR sky130_fd_sc_hd__decap_3
X_4857_ _5015_/A _5655_/D wire554/X VGND VGND VPWR VPWR _4857_/X sky130_fd_sc_hd__or3b_4
XFILLER_20_253 VGND VGND VPWR VPWR sky130_fd_sc_hd__decap_3
X_3808_ _6929_/Q _3906_/A2 _3907_/A2 _6793_/Q _3807_/X VGND VGND VPWR VPWR _3808_/X
+ sky130_fd_sc_hd__a221o_2
XFILLER_109_12 VGND VGND VPWR VPWR sky130_fd_sc_hd__decap_3
XFILLER_20_286 VGND VGND VPWR VPWR sky130_fd_sc_hd__decap_3
X_6527_ _6637_/A VGND VGND VPWR VPWR _6527_/Y sky130_fd_sc_hd__inv_2
X_4788_ _4788_/A _4788_/B VGND VGND VPWR VPWR _4788_/Y sky130_fd_sc_hd__nand2_2
XFILLER_109_45 VGND VGND VPWR VPWR sky130_fd_sc_hd__decap_3
X_3739_ _6936_/Q _3902_/A2 _3913_/A2 _6800_/Q VGND VGND VPWR VPWR _3739_/X sky130_fd_sc_hd__a22o_2
XFILLER_109_78 VGND VGND VPWR VPWR sky130_fd_sc_hd__decap_3
XFILLER_69_27 VGND VGND VPWR VPWR sky130_fd_sc_hd__decap_3
XFILLER_69_38 VGND VGND VPWR VPWR sky130_fd_sc_hd__decap_3
X_6458_ _6682_/A VGND VGND VPWR VPWR _6458_/Y sky130_fd_sc_hd__inv_2
X_6389_ _6611_/A VGND VGND VPWR VPWR _6389_/Y sky130_fd_sc_hd__inv_2
X_5409_ _5409_/A0 _5079_/X _5429_/S VGND VGND VPWR VPWR _7129_/D sky130_fd_sc_hd__mux2_2
XFILLER_102_531 VGND VGND VPWR VPWR sky130_fd_sc_hd__fill_1
XFILLER_102_564 VGND VGND VPWR VPWR sky130_fd_sc_hd__decap_3
XFILLER_48_607 VGND VGND VPWR VPWR sky130_fd_sc_hd__decap_3
XFILLER_85_26 VGND VGND VPWR VPWR sky130_fd_sc_hd__decap_3
XFILLER_47_128 VGND VGND VPWR VPWR sky130_fd_sc_hd__decap_3
XFILLER_75_437 VGND VGND VPWR VPWR sky130_fd_sc_hd__fill_1
XFILLER_85_48 VGND VGND VPWR VPWR sky130_fd_sc_hd__decap_3
XFILLER_87_275 VGND VGND VPWR VPWR sky130_fd_sc_hd__decap_3
XTAP_TAPCELL_ROW_89_1316 VGND VPWR sky130_fd_sc_hd__tapvpwrvgnd_1
XFILLER_18_53 VGND VGND VPWR VPWR sky130_fd_sc_hd__fill_1
XFILLER_56_640 VGND VGND VPWR VPWR sky130_fd_sc_hd__decap_3
XFILLER_56_651 VGND VGND VPWR VPWR sky130_fd_sc_hd__decap_3
XFILLER_75_459 VGND VGND VPWR VPWR sky130_fd_sc_hd__decap_3
XFILLER_16_515 VGND VGND VPWR VPWR sky130_fd_sc_hd__decap_3
XFILLER_18_64 VGND VGND VPWR VPWR sky130_fd_sc_hd__decap_3
XFILLER_71_610 VGND VGND VPWR VPWR sky130_fd_sc_hd__decap_3
XFILLER_90_407 VGND VGND VPWR VPWR sky130_fd_sc_hd__decap_3
XTAP_TAPCELL_ROW_46_808 VGND VPWR sky130_fd_sc_hd__tapvpwrvgnd_1
XFILLER_43_323 VGND VGND VPWR VPWR sky130_fd_sc_hd__decap_3
XFILLER_55_172 VGND VGND VPWR VPWR sky130_fd_sc_hd__fill_2
XFILLER_55_183 VGND VGND VPWR VPWR sky130_fd_sc_hd__decap_3
XFILLER_71_632 VGND VGND VPWR VPWR sky130_fd_sc_hd__decap_3
XFILLER_83_492 VGND VGND VPWR VPWR sky130_fd_sc_hd__decap_3
XFILLER_70_153 VGND VGND VPWR VPWR sky130_fd_sc_hd__decap_3
XFILLER_71_665 VGND VGND VPWR VPWR sky130_fd_sc_hd__decap_3
XFILLER_71_676 VGND VGND VPWR VPWR sky130_fd_sc_hd__decap_3
XTAP_TAPCELL_ROW_54_896 VGND VPWR sky130_fd_sc_hd__tapvpwrvgnd_1
XTAP_TAPCELL_ROW_26_565 VGND VPWR sky130_fd_sc_hd__tapvpwrvgnd_1
XFILLER_11_231 VGND VGND VPWR VPWR sky130_fd_sc_hd__decap_3
XFILLER_34_85 VGND VGND VPWR VPWR sky130_fd_sc_hd__decap_3
XFILLER_70_197 VGND VGND VPWR VPWR sky130_fd_sc_hd__decap_3
XFILLER_11_264 VGND VGND VPWR VPWR sky130_fd_sc_hd__decap_3
XFILLER_50_40 VGND VGND VPWR VPWR sky130_fd_sc_hd__decap_3
XFILLER_109_152 VGND VGND VPWR VPWR sky130_fd_sc_hd__decap_3
XFILLER_50_73 VGND VGND VPWR VPWR sky130_fd_sc_hd__fill_1
XFILLER_7_268 VGND VGND VPWR VPWR sky130_fd_sc_hd__decap_3
XFILLER_109_196 VGND VGND VPWR VPWR sky130_fd_sc_hd__decap_3
XFILLER_50_95 VGND VGND VPWR VPWR sky130_fd_sc_hd__fill_1
XFILLER_3_441 VGND VGND VPWR VPWR sky130_fd_sc_hd__decap_3
XFILLER_3_452 VGND VGND VPWR VPWR sky130_fd_sc_hd__decap_3
XFILLER_105_380 VGND VGND VPWR VPWR sky130_fd_sc_hd__decap_3
XFILLER_59_60 VGND VGND VPWR VPWR sky130_fd_sc_hd__decap_3
XFILLER_78_253 VGND VGND VPWR VPWR sky130_fd_sc_hd__fill_2
XFILLER_66_415 VGND VGND VPWR VPWR sky130_fd_sc_hd__decap_3
XFILLER_66_437 VGND VGND VPWR VPWR sky130_fd_sc_hd__decap_3
XFILLER_15_6 VGND VGND VPWR VPWR sky130_fd_sc_hd__decap_3
XFILLER_78_297 VGND VGND VPWR VPWR sky130_fd_sc_hd__decap_3
XFILLER_93_223 VGND VGND VPWR VPWR sky130_fd_sc_hd__fill_1
XFILLER_46_150 VGND VGND VPWR VPWR sky130_fd_sc_hd__decap_3
XFILLER_47_662 VGND VGND VPWR VPWR sky130_fd_sc_hd__decap_3
XFILLER_47_673 VGND VGND VPWR VPWR sky130_fd_sc_hd__decap_3
XFILLER_75_81 VGND VGND VPWR VPWR sky130_fd_sc_hd__decap_3
XFILLER_81_407 VGND VGND VPWR VPWR sky130_fd_sc_hd__decap_3
XFILLER_93_289 VGND VGND VPWR VPWR sky130_fd_sc_hd__fill_2
XTAP_TAPCELL_ROW_109_1563 VGND VPWR sky130_fd_sc_hd__tapvpwrvgnd_1
XFILLER_34_312 VGND VGND VPWR VPWR sky130_fd_sc_hd__decap_3
XFILLER_46_194 VGND VGND VPWR VPWR sky130_fd_sc_hd__fill_2
XFILLER_62_610 VGND VGND VPWR VPWR sky130_fd_sc_hd__decap_3
XFILLER_62_643 VGND VGND VPWR VPWR sky130_fd_sc_hd__fill_1
XFILLER_75_92 VGND VGND VPWR VPWR sky130_fd_sc_hd__decap_3
XFILLER_34_345 VGND VGND VPWR VPWR sky130_fd_sc_hd__decap_3
XFILLER_61_131 VGND VGND VPWR VPWR sky130_fd_sc_hd__decap_3
XFILLER_62_654 VGND VGND VPWR VPWR sky130_fd_sc_hd__decap_3
XFILLER_62_687 VGND VGND VPWR VPWR sky130_fd_sc_hd__decap_3
XFILLER_98_3 VGND VGND VPWR VPWR sky130_fd_sc_hd__decap_3
X_4711_ _7005_/Q _7006_/Q _4775_/A VGND VGND VPWR VPWR _4738_/A sky130_fd_sc_hd__and3_2
XFILLER_30_562 VGND VGND VPWR VPWR sky130_fd_sc_hd__decap_3
XFILLER_30_573 VGND VGND VPWR VPWR sky130_fd_sc_hd__decap_3
X_4642_ _4207_/A _4642_/B VGND VGND VPWR VPWR _4888_/A sky130_fd_sc_hd__and2b_2
XFILLER_30_595 VGND VGND VPWR VPWR sky130_fd_sc_hd__fill_1
XFILLER_116_612 VGND VGND VPWR VPWR sky130_fd_sc_hd__decap_3
XFILLER_116_623 VGND VGND VPWR VPWR sky130_fd_sc_hd__decap_3
X_7361_ _7403_/CLK _7361_/D _6641_/Y VGND VGND VPWR VPWR _7361_/Q sky130_fd_sc_hd__dfrtp_2
Xhold703 _6881_/Q VGND VGND VPWR VPWR _6881_/D sky130_fd_sc_hd__dlygate4sd3_1
X_4573_ _4573_/A _4577_/B VGND VGND VPWR VPWR _7294_/D sky130_fd_sc_hd__and2_2
XFILLER_115_111 VGND VGND VPWR VPWR sky130_fd_sc_hd__fill_1
XFILLER_115_122 VGND VGND VPWR VPWR sky130_fd_sc_hd__decap_3
XFILLER_116_645 VGND VGND VPWR VPWR sky130_fd_sc_hd__decap_3
X_7292_ _7294_/CLK _7292_/D _6572_/Y VGND VGND VPWR VPWR _7292_/Q sky130_fd_sc_hd__dfrtp_2
Xhold714 _6846_/Q VGND VGND VPWR VPWR _6846_/D sky130_fd_sc_hd__dlygate4sd3_1
Xhold725 _6824_/Q VGND VGND VPWR VPWR _6824_/D sky130_fd_sc_hd__dlygate4sd3_1
Xhold736 _6734_/Q VGND VGND VPWR VPWR _6734_/D sky130_fd_sc_hd__dlygate4sd3_1
X_6312_ _6634_/A VGND VGND VPWR VPWR _6312_/Y sky130_fd_sc_hd__inv_2
XFILLER_115_155 VGND VGND VPWR VPWR sky130_fd_sc_hd__decap_3
Xhold747 _6733_/Q VGND VGND VPWR VPWR _6733_/D sky130_fd_sc_hd__dlygate4sd3_1
Xhold758 _6962_/Q VGND VGND VPWR VPWR _6962_/D sky130_fd_sc_hd__dlygate4sd3_1
Xhold769 _6860_/Q VGND VGND VPWR VPWR _6860_/D sky130_fd_sc_hd__dlygate4sd3_1
X_3455_ _7346_/Q _4337_/B _3454_/X VGND VGND VPWR VPWR _3455_/X sky130_fd_sc_hd__a21o_2
XTAP_TAPCELL_ROW_73_1128 VGND VPWR sky130_fd_sc_hd__tapvpwrvgnd_1
XFILLER_115_199 VGND VGND VPWR VPWR sky130_fd_sc_hd__decap_3
XFILLER_69_220 VGND VGND VPWR VPWR sky130_fd_sc_hd__decap_3
XFILLER_69_231 VGND VGND VPWR VPWR sky130_fd_sc_hd__decap_3
XFILLER_97_551 VGND VGND VPWR VPWR sky130_fd_sc_hd__decap_3
X_3386_ _3561_/A _3386_/B VGND VGND VPWR VPWR _3386_/Y sky130_fd_sc_hd__nand2_2
XFILLER_69_275 VGND VGND VPWR VPWR sky130_fd_sc_hd__decap_3
X_5125_ _5156_/S _5125_/B VGND VGND VPWR VPWR _5125_/Y sky130_fd_sc_hd__nand2_2
XFILLER_29_128 VGND VGND VPWR VPWR sky130_fd_sc_hd__decap_3
XFILLER_29_139 VGND VGND VPWR VPWR sky130_fd_sc_hd__decap_3
X_5056_ _3536_/B _4619_/B _5052_/X _5055_/X VGND VGND VPWR VPWR _5056_/X sky130_fd_sc_hd__o31a_2
XFILLER_37_150 VGND VGND VPWR VPWR sky130_fd_sc_hd__fill_1
XFILLER_44_109 VGND VGND VPWR VPWR sky130_fd_sc_hd__decap_3
XFILLER_55_18 VGND VGND VPWR VPWR sky130_fd_sc_hd__decap_3
XFILLER_25_334 VGND VGND VPWR VPWR sky130_fd_sc_hd__fill_2
XFILLER_37_183 VGND VGND VPWR VPWR sky130_fd_sc_hd__decap_3
XFILLER_38_684 VGND VGND VPWR VPWR sky130_fd_sc_hd__decap_3
XFILLER_53_610 VGND VGND VPWR VPWR sky130_fd_sc_hd__decap_3
XFILLER_53_632 VGND VGND VPWR VPWR sky130_fd_sc_hd__decap_3
XFILLER_65_492 VGND VGND VPWR VPWR sky130_fd_sc_hd__fill_1
XFILLER_111_35 VGND VGND VPWR VPWR sky130_fd_sc_hd__decap_3
XFILLER_53_665 VGND VGND VPWR VPWR sky130_fd_sc_hd__decap_3
XFILLER_53_676 VGND VGND VPWR VPWR sky130_fd_sc_hd__decap_3
XTAP_TAPCELL_ROW_84_1257 VGND VPWR sky130_fd_sc_hd__tapvpwrvgnd_1
XFILLER_111_57 VGND VGND VPWR VPWR sky130_fd_sc_hd__decap_3
XFILLER_13_518 VGND VGND VPWR VPWR sky130_fd_sc_hd__decap_3
XFILLER_40_315 VGND VGND VPWR VPWR sky130_fd_sc_hd__decap_3
XFILLER_52_164 VGND VGND VPWR VPWR sky130_fd_sc_hd__decap_3
XFILLER_80_495 VGND VGND VPWR VPWR sky130_fd_sc_hd__decap_3
X_4909_ _4909_/A _4909_/B _4909_/C VGND VGND VPWR VPWR _4910_/B sky130_fd_sc_hd__or3_2
XTAP_TAPCELL_ROW_23_524 VGND VPWR sky130_fd_sc_hd__tapvpwrvgnd_1
XTAP_TAPCELL_ROW_51_866 VGND VPWR sky130_fd_sc_hd__tapvpwrvgnd_1
XFILLER_107_623 VGND VGND VPWR VPWR sky130_fd_sc_hd__decap_3
XFILLER_106_100 VGND VGND VPWR VPWR sky130_fd_sc_hd__decap_3
XFILLER_107_656 VGND VGND VPWR VPWR sky130_fd_sc_hd__decap_3
XFILLER_20_21 VGND VGND VPWR VPWR sky130_fd_sc_hd__decap_3
XFILLER_20_43 VGND VGND VPWR VPWR sky130_fd_sc_hd__decap_3
XFILLER_20_76 VGND VGND VPWR VPWR sky130_fd_sc_hd__decap_3
XTAP_TAPCELL_ROW_95_1397 VGND VPWR sky130_fd_sc_hd__tapvpwrvgnd_1
XTAP_TAPCELL_ROW_95_1386 VGND VPWR sky130_fd_sc_hd__tapvpwrvgnd_1
XFILLER_106_188 VGND VGND VPWR VPWR sky130_fd_sc_hd__decap_3
XFILLER_96_14 VGND VGND VPWR VPWR sky130_fd_sc_hd__decap_3
XFILLER_0_433 VGND VGND VPWR VPWR sky130_fd_sc_hd__decap_3
XFILLER_0_455 VGND VGND VPWR VPWR sky130_fd_sc_hd__decap_3
XFILLER_102_350 VGND VGND VPWR VPWR sky130_fd_sc_hd__decap_3
XFILLER_29_52 VGND VGND VPWR VPWR sky130_fd_sc_hd__decap_3
XFILLER_88_584 VGND VGND VPWR VPWR sky130_fd_sc_hd__decap_3
XFILLER_29_63 VGND VGND VPWR VPWR sky130_fd_sc_hd__decap_3
XFILLER_29_96 VGND VGND VPWR VPWR sky130_fd_sc_hd__decap_3
XTAP_TAPCELL_ROW_59_955 VGND VPWR sky130_fd_sc_hd__tapvpwrvgnd_1
XFILLER_29_673 VGND VGND VPWR VPWR sky130_fd_sc_hd__fill_2
XFILLER_63_418 VGND VGND VPWR VPWR sky130_fd_sc_hd__decap_3
XFILLER_75_278 VGND VGND VPWR VPWR sky130_fd_sc_hd__fill_2
XFILLER_16_301 VGND VGND VPWR VPWR sky130_fd_sc_hd__decap_3
XFILLER_16_312 VGND VGND VPWR VPWR sky130_fd_sc_hd__decap_3
XFILLER_56_470 VGND VGND VPWR VPWR sky130_fd_sc_hd__decap_3
Xplace407 _4505_/S VGND VGND VPWR VPWR _4493_/S sky130_fd_sc_hd__buf_2
Xplace418 _3371_/Y VGND VGND VPWR VPWR _3977_/S sky130_fd_sc_hd__buf_2
Xplace429 _4471_/S VGND VGND VPWR VPWR _3996_/S sky130_fd_sc_hd__buf_2
XTAP_TAPCELL_ROW_3_293 VGND VPWR sky130_fd_sc_hd__tapvpwrvgnd_1
XTAP_TAPCELL_ROW_3_282 VGND VPWR sky130_fd_sc_hd__tapvpwrvgnd_1
XFILLER_16_345 VGND VGND VPWR VPWR sky130_fd_sc_hd__decap_3
XFILLER_44_676 VGND VGND VPWR VPWR sky130_fd_sc_hd__decap_3
XFILLER_90_259 VGND VGND VPWR VPWR sky130_fd_sc_hd__decap_3
XFILLER_16_389 VGND VGND VPWR VPWR sky130_fd_sc_hd__decap_3
XFILLER_71_473 VGND VGND VPWR VPWR sky130_fd_sc_hd__decap_3
XFILLER_31_337 VGND VGND VPWR VPWR sky130_fd_sc_hd__fill_2
XFILLER_31_348 VGND VGND VPWR VPWR sky130_fd_sc_hd__decap_3
XFILLER_61_61 VGND VGND VPWR VPWR sky130_fd_sc_hd__fill_1
XFILLER_84_9 VGND VGND VPWR VPWR sky130_fd_sc_hd__decap_3
XFILLER_12_584 VGND VGND VPWR VPWR sky130_fd_sc_hd__decap_3
XFILLER_61_94 VGND VGND VPWR VPWR sky130_fd_sc_hd__decap_3
XFILLER_8_533 VGND VGND VPWR VPWR sky130_fd_sc_hd__decap_3
XFILLER_8_544 VGND VGND VPWR VPWR sky130_fd_sc_hd__fill_2
XFILLER_6_12 VGND VGND VPWR VPWR sky130_fd_sc_hd__decap_3
XFILLER_8_566 VGND VGND VPWR VPWR sky130_fd_sc_hd__decap_3
XANTENNA_5 _5647_/Y VGND VGND VPWR VPWR sky130_fd_sc_hd__diode_2
XFILLER_6_56 VGND VGND VPWR VPWR sky130_fd_sc_hd__decap_3
XFILLER_113_615 VGND VGND VPWR VPWR sky130_fd_sc_hd__fill_1
XFILLER_112_103 VGND VGND VPWR VPWR sky130_fd_sc_hd__decap_3
XFILLER_113_626 VGND VGND VPWR VPWR sky130_fd_sc_hd__decap_3
XFILLER_98_337 VGND VGND VPWR VPWR sky130_fd_sc_hd__decap_3
XFILLER_112_136 VGND VGND VPWR VPWR sky130_fd_sc_hd__decap_3
XFILLER_112_147 VGND VGND VPWR VPWR sky130_fd_sc_hd__decap_3
XFILLER_113_659 VGND VGND VPWR VPWR sky130_fd_sc_hd__decap_3
XFILLER_100_309 VGND VGND VPWR VPWR sky130_fd_sc_hd__fill_2
XFILLER_79_573 VGND VGND VPWR VPWR sky130_fd_sc_hd__decap_3
XFILLER_39_437 VGND VGND VPWR VPWR sky130_fd_sc_hd__decap_3
XFILLER_66_234 VGND VGND VPWR VPWR sky130_fd_sc_hd__decap_3
XFILLER_86_91 VGND VGND VPWR VPWR sky130_fd_sc_hd__decap_3
XFILLER_54_407 VGND VGND VPWR VPWR sky130_fd_sc_hd__decap_3
XFILLER_66_256 VGND VGND VPWR VPWR sky130_fd_sc_hd__decap_3
XFILLER_35_632 VGND VGND VPWR VPWR sky130_fd_sc_hd__decap_3
X_6930_ _6975_/CLK _6930_/D VGND VGND VPWR VPWR _6930_/Q sky130_fd_sc_hd__dfxtp_2
X_6861_ _6978_/CLK _6861_/D VGND VGND VPWR VPWR _6861_/Q sky130_fd_sc_hd__dfxtp_2
XFILLER_34_153 VGND VGND VPWR VPWR sky130_fd_sc_hd__fill_2
XFILLER_34_164 VGND VGND VPWR VPWR sky130_fd_sc_hd__decap_3
XFILLER_35_676 VGND VGND VPWR VPWR sky130_fd_sc_hd__decap_3
XFILLER_50_624 VGND VGND VPWR VPWR sky130_fd_sc_hd__decap_3
X_6792_ _7392_/CLK _6792_/D VGND VGND VPWR VPWR _6792_/Q sky130_fd_sc_hd__dfxtp_2
XFILLER_34_197 VGND VGND VPWR VPWR sky130_fd_sc_hd__decap_3
XFILLER_50_657 VGND VGND VPWR VPWR sky130_fd_sc_hd__decap_3
X_5674_ _7343_/Q hold923/X _5706_/S VGND VGND VPWR VPWR _5674_/X sky130_fd_sc_hd__mux2_2
X_4625_ _5099_/A wire560/X _4624_/B _4624_/X VGND VGND VPWR VPWR _4916_/A sky130_fd_sc_hd__a31oi_4
X_7344_ _7387_/CLK _7344_/D _6624_/Y VGND VGND VPWR VPWR _7344_/Q sky130_fd_sc_hd__dfrtp_2
X_4556_ _4556_/A _4571_/B VGND VGND VPWR VPWR _7302_/D sky130_fd_sc_hd__and2_2
X_3507_ _3458_/Y _3505_/X _3506_/Y VGND VGND VPWR VPWR _3508_/B sky130_fd_sc_hd__o21a_2
XFILLER_104_637 VGND VGND VPWR VPWR sky130_fd_sc_hd__decap_3
XFILLER_104_648 VGND VGND VPWR VPWR sky130_fd_sc_hd__decap_3
XFILLER_116_486 VGND VGND VPWR VPWR sky130_fd_sc_hd__decap_3
XFILLER_89_337 VGND VGND VPWR VPWR sky130_fd_sc_hd__decap_3
X_7275_ _7310_/CLK _7275_/D _6555_/Y VGND VGND VPWR VPWR _7275_/Q sky130_fd_sc_hd__dfrtp_2
Xhold588 _6932_/Q VGND VGND VPWR VPWR _6932_/D sky130_fd_sc_hd__dlygate4sd3_1
XFILLER_103_125 VGND VGND VPWR VPWR sky130_fd_sc_hd__decap_3
XFILLER_103_136 VGND VGND VPWR VPWR sky130_fd_sc_hd__decap_3
XFILLER_106_24 VGND VGND VPWR VPWR sky130_fd_sc_hd__decap_3
XFILLER_106_35 VGND VGND VPWR VPWR sky130_fd_sc_hd__decap_3
XFILLER_89_359 VGND VGND VPWR VPWR sky130_fd_sc_hd__decap_3
Xhold599 _6915_/Q VGND VGND VPWR VPWR _6915_/D sky130_fd_sc_hd__dlygate4sd3_1
X_3438_ _7314_/Q _3989_/S _4338_/B1 _7346_/Q _4347_/C1 VGND VGND VPWR VPWR _3438_/X
+ sky130_fd_sc_hd__a221o_2
XFILLER_106_68 VGND VGND VPWR VPWR sky130_fd_sc_hd__decap_3
XFILLER_112_681 VGND VGND VPWR VPWR sky130_fd_sc_hd__decap_3
XFILLER_57_201 VGND VGND VPWR VPWR sky130_fd_sc_hd__decap_3
Xhold1200 _7009_/Q VGND VGND VPWR VPWR _7009_/D sky130_fd_sc_hd__dlygate4sd3_1
X_3369_ _3371_/A _5668_/A VGND VGND VPWR VPWR _3560_/B sky130_fd_sc_hd__nand2_2
XFILLER_57_245 VGND VGND VPWR VPWR sky130_fd_sc_hd__decap_3
XFILLER_97_381 VGND VGND VPWR VPWR sky130_fd_sc_hd__decap_3
Xhold1211 _7345_/Q VGND VGND VPWR VPWR _3994_/A0 sky130_fd_sc_hd__dlygate4sd3_1
Xhold1222 _7326_/Q VGND VGND VPWR VPWR _4507_/A0 sky130_fd_sc_hd__dlygate4sd3_1
Xhold1233 _7325_/Q VGND VGND VPWR VPWR _3966_/A1 sky130_fd_sc_hd__dlygate4sd3_1
X_5108_ _5108_/A0 _5107_/X _5136_/S VGND VGND VPWR VPWR _7255_/D sky130_fd_sc_hd__mux2_2
XFILLER_57_278 VGND VGND VPWR VPWR sky130_fd_sc_hd__fill_2
X_5039_ _4677_/B _3856_/X _5658_/B _5038_/X _5598_/A2 VGND VGND VPWR VPWR _5039_/X
+ sky130_fd_sc_hd__o32a_2
XTAP_TAPCELL_ROW_56_925 VGND VPWR sky130_fd_sc_hd__tapvpwrvgnd_1
XFILLER_82_27 VGND VGND VPWR VPWR sky130_fd_sc_hd__fill_1
XFILLER_82_38 VGND VGND VPWR VPWR sky130_fd_sc_hd__decap_3
XTAP_TAPCELL_ROW_0_252 VGND VPWR sky130_fd_sc_hd__tapvpwrvgnd_1
XTAP_TAPCELL_ROW_0_241 VGND VPWR sky130_fd_sc_hd__tapvpwrvgnd_1
XFILLER_15_21 VGND VGND VPWR VPWR sky130_fd_sc_hd__decap_3
XFILLER_26_687 VGND VGND VPWR VPWR sky130_fd_sc_hd__decap_3
XFILLER_13_326 VGND VGND VPWR VPWR sky130_fd_sc_hd__decap_3
XFILLER_15_54 VGND VGND VPWR VPWR sky130_fd_sc_hd__fill_2
XFILLER_25_186 VGND VGND VPWR VPWR sky130_fd_sc_hd__fill_1
XFILLER_80_292 VGND VGND VPWR VPWR sky130_fd_sc_hd__decap_3
XTAP_TAPCELL_ROW_36_682 VGND VPWR sky130_fd_sc_hd__tapvpwrvgnd_1
XFILLER_40_167 VGND VGND VPWR VPWR sky130_fd_sc_hd__decap_3
XFILLER_41_668 VGND VGND VPWR VPWR sky130_fd_sc_hd__decap_3
XFILLER_41_679 VGND VGND VPWR VPWR sky130_fd_sc_hd__decap_3
XTAP_TAPCELL_ROW_97_1415 VGND VPWR sky130_fd_sc_hd__tapvpwrvgnd_1
XFILLER_31_75 VGND VGND VPWR VPWR sky130_fd_sc_hd__decap_3
XFILLER_107_442 VGND VGND VPWR VPWR sky130_fd_sc_hd__decap_3
XFILLER_31_97 VGND VGND VPWR VPWR sky130_fd_sc_hd__decap_3
XFILLER_107_475 VGND VGND VPWR VPWR sky130_fd_sc_hd__decap_3
XFILLER_110_607 VGND VGND VPWR VPWR sky130_fd_sc_hd__decap_3
XTAP_TAPCELL_ROW_8_352 VGND VPWR sky130_fd_sc_hd__tapvpwrvgnd_1
XFILLER_76_510 VGND VGND VPWR VPWR sky130_fd_sc_hd__decap_3
XFILLER_88_392 VGND VGND VPWR VPWR sky130_fd_sc_hd__decap_3
XFILLER_48_256 VGND VGND VPWR VPWR sky130_fd_sc_hd__fill_2
XFILLER_48_267 VGND VGND VPWR VPWR sky130_fd_sc_hd__decap_3
XFILLER_76_587 VGND VGND VPWR VPWR sky130_fd_sc_hd__fill_1
XFILLER_17_610 VGND VGND VPWR VPWR sky130_fd_sc_hd__decap_3
XFILLER_29_470 VGND VGND VPWR VPWR sky130_fd_sc_hd__decap_3
XFILLER_56_72 VGND VGND VPWR VPWR sky130_fd_sc_hd__fill_1
XFILLER_63_237 VGND VGND VPWR VPWR sky130_fd_sc_hd__fill_2
XFILLER_16_131 VGND VGND VPWR VPWR sky130_fd_sc_hd__decap_3
XFILLER_17_643 VGND VGND VPWR VPWR sky130_fd_sc_hd__decap_3
XFILLER_91_557 VGND VGND VPWR VPWR sky130_fd_sc_hd__decap_3
XTAP_TAPCELL_ROW_106_1522 VGND VPWR sky130_fd_sc_hd__tapvpwrvgnd_1
XFILLER_16_197 VGND VGND VPWR VPWR sky130_fd_sc_hd__decap_3
XFILLER_71_292 VGND VGND VPWR VPWR sky130_fd_sc_hd__decap_3
XFILLER_72_82 VGND VGND VPWR VPWR sky130_fd_sc_hd__fill_2
XFILLER_82_6 VGND VGND VPWR VPWR sky130_fd_sc_hd__decap_3
XFILLER_8_363 VGND VGND VPWR VPWR sky130_fd_sc_hd__fill_1
X_4410_ _4411_/A _4411_/B VGND VGND VPWR VPWR _4788_/B sky130_fd_sc_hd__nor2_2
X_5390_ _5390_/A0 _4932_/X _5396_/S VGND VGND VPWR VPWR _7138_/D sky130_fd_sc_hd__mux2_2
XFILLER_113_412 VGND VGND VPWR VPWR sky130_fd_sc_hd__decap_3
X_4341_ _7255_/Q _4341_/A2 _4348_/B1 _7127_/Q _4340_/X VGND VGND VPWR VPWR _4365_/A
+ sky130_fd_sc_hd__a221o_2
XFILLER_99_635 VGND VGND VPWR VPWR sky130_fd_sc_hd__decap_3
X_7060_ clkload6/A _7060_/D _6340_/Y VGND VGND VPWR VPWR _7060_/Q sky130_fd_sc_hd__dfrtp_2
X_4272_ _4394_/A _4272_/B _4271_/X VGND VGND VPWR VPWR _4273_/D sky130_fd_sc_hd__or3b_2
XFILLER_99_679 VGND VGND VPWR VPWR sky130_fd_sc_hd__decap_3
XFILLER_99_668 VGND VGND VPWR VPWR sky130_fd_sc_hd__decap_3
XFILLER_101_629 VGND VGND VPWR VPWR sky130_fd_sc_hd__decap_3
XFILLER_98_167 VGND VGND VPWR VPWR sky130_fd_sc_hd__fill_2
XFILLER_100_128 VGND VGND VPWR VPWR sky130_fd_sc_hd__decap_3
XFILLER_39_212 VGND VGND VPWR VPWR sky130_fd_sc_hd__decap_3
XFILLER_94_362 VGND VGND VPWR VPWR sky130_fd_sc_hd__fill_2
XFILLER_54_215 VGND VGND VPWR VPWR sky130_fd_sc_hd__decap_3
XFILLER_54_259 VGND VGND VPWR VPWR sky130_fd_sc_hd__decap_3
X_6913_ _7386_/CLK _6913_/D VGND VGND VPWR VPWR _6913_/Q sky130_fd_sc_hd__dfxtp_2
XFILLER_22_101 VGND VGND VPWR VPWR sky130_fd_sc_hd__decap_3
XFILLER_50_410 VGND VGND VPWR VPWR sky130_fd_sc_hd__fill_1
XFILLER_50_432 VGND VGND VPWR VPWR sky130_fd_sc_hd__fill_2
X_6844_ _6946_/CLK _6844_/D VGND VGND VPWR VPWR _6844_/Q sky130_fd_sc_hd__dfxtp_2
XTAP_TAPCELL_ROW_81_1227 VGND VPWR sky130_fd_sc_hd__tapvpwrvgnd_1
X_6775_ _6971_/CLK _6775_/D VGND VGND VPWR VPWR _6775_/Q sky130_fd_sc_hd__dfxtp_2
X_3987_ _7347_/Q _4528_/A _3987_/S VGND VGND VPWR VPWR _7347_/D sky130_fd_sc_hd__mux2_2
XTAP_TAPCELL_ROW_33_652 VGND VPWR sky130_fd_sc_hd__tapvpwrvgnd_1
XFILLER_10_318 VGND VGND VPWR VPWR sky130_fd_sc_hd__decap_3
XTAP_TAPCELL_ROW_61_983 VGND VPWR sky130_fd_sc_hd__tapvpwrvgnd_1
XFILLER_108_206 VGND VGND VPWR VPWR sky130_fd_sc_hd__decap_3
X_5657_ _5657_/A _5657_/B _5657_/C _5657_/D VGND VGND VPWR VPWR _5664_/C sky130_fd_sc_hd__nor4_2
X_4608_ _4938_/A _4608_/B VGND VGND VPWR VPWR _4608_/Y sky130_fd_sc_hd__nor2_2
X_7327_ _7364_/CLK _7327_/D _6607_/Y VGND VGND VPWR VPWR _7327_/Q sky130_fd_sc_hd__dfrtp_2
XFILLER_104_456 VGND VGND VPWR VPWR sky130_fd_sc_hd__decap_3
XFILLER_89_123 VGND VGND VPWR VPWR sky130_fd_sc_hd__decap_3
X_7258_ clkload8/A _7258_/D _6538_/Y VGND VGND VPWR VPWR _7258_/Q sky130_fd_sc_hd__dfrtp_2
XTAP_TAPCELL_ROW_92_1356 VGND VPWR sky130_fd_sc_hd__tapvpwrvgnd_1
XFILLER_77_307 VGND VGND VPWR VPWR sky130_fd_sc_hd__decap_3
XFILLER_77_38 VGND VGND VPWR VPWR sky130_fd_sc_hd__decap_3
XTAP_TAPCELL_ROW_5_311 VGND VPWR sky130_fd_sc_hd__tapvpwrvgnd_1
X_7189_ clkload6/A _7189_/D _6469_/Y VGND VGND VPWR VPWR _7189_/Q sky130_fd_sc_hd__dfrtp_2
XFILLER_100_651 VGND VGND VPWR VPWR sky130_fd_sc_hd__decap_3
XFILLER_93_15 VGND VGND VPWR VPWR sky130_fd_sc_hd__decap_3
Xhold1030 _7197_/Q VGND VGND VPWR VPWR _5266_/A0 sky130_fd_sc_hd__dlygate4sd3_1
Xhold1041 _7271_/Q VGND VGND VPWR VPWR _4837_/A0 sky130_fd_sc_hd__dlygate4sd3_1
XFILLER_100_684 VGND VGND VPWR VPWR sky130_fd_sc_hd__decap_3
XFILLER_18_418 VGND VGND VPWR VPWR sky130_fd_sc_hd__fill_2
XFILLER_58_587 VGND VGND VPWR VPWR sky130_fd_sc_hd__fill_1
XFILLER_58_598 VGND VGND VPWR VPWR sky130_fd_sc_hd__decap_3
XFILLER_85_373 VGND VGND VPWR VPWR sky130_fd_sc_hd__decap_3
Xhold1052 _7207_/Q VGND VGND VPWR VPWR _5245_/A0 sky130_fd_sc_hd__dlygate4sd3_1
Xhold1063 _7239_/Q VGND VGND VPWR VPWR _5177_/A sky130_fd_sc_hd__dlygate4sd3_1
Xhold1074 _7393_/Q VGND VGND VPWR VPWR _3770_/A1 sky130_fd_sc_hd__dlygate4sd3_1
Xhold1085 _7316_/Q VGND VGND VPWR VPWR _4526_/A0 sky130_fd_sc_hd__dlygate4sd3_1
XFILLER_26_42 VGND VGND VPWR VPWR sky130_fd_sc_hd__decap_3
XFILLER_45_237 VGND VGND VPWR VPWR sky130_fd_sc_hd__decap_3
XFILLER_45_259 VGND VGND VPWR VPWR sky130_fd_sc_hd__fill_1
XFILLER_73_557 VGND VGND VPWR VPWR sky130_fd_sc_hd__decap_3
Xhold1096 _7214_/Q VGND VGND VPWR VPWR _5232_/A0 sky130_fd_sc_hd__dlygate4sd3_1
Xclkbuf_3_6__f_clk clkbuf_0_clk/X VGND VGND VPWR VPWR clkbuf_3_6__f_clk/X sky130_fd_sc_hd__clkbuf_16
XFILLER_13_101 VGND VGND VPWR VPWR sky130_fd_sc_hd__decap_3
XFILLER_26_97 VGND VGND VPWR VPWR sky130_fd_sc_hd__decap_3
XFILLER_41_421 VGND VGND VPWR VPWR sky130_fd_sc_hd__decap_3
XFILLER_53_270 VGND VGND VPWR VPWR sky130_fd_sc_hd__decap_3
XFILLER_53_281 VGND VGND VPWR VPWR sky130_fd_sc_hd__decap_3
XFILLER_13_145 VGND VGND VPWR VPWR sky130_fd_sc_hd__fill_1
XFILLER_13_167 VGND VGND VPWR VPWR sky130_fd_sc_hd__fill_1
XFILLER_41_443 VGND VGND VPWR VPWR sky130_fd_sc_hd__decap_3
XFILLER_9_116 VGND VGND VPWR VPWR sky130_fd_sc_hd__decap_3
XFILLER_9_105 VGND VGND VPWR VPWR sky130_fd_sc_hd__decap_3
XTAP_TAPCELL_ROW_101_1463 VGND VPWR sky130_fd_sc_hd__tapvpwrvgnd_1
XFILLER_42_63 VGND VGND VPWR VPWR sky130_fd_sc_hd__fill_1
XFILLER_42_74 VGND VGND VPWR VPWR sky130_fd_sc_hd__fill_1
XFILLER_42_85 VGND VGND VPWR VPWR sky130_fd_sc_hd__decap_3
XFILLER_5_322 VGND VGND VPWR VPWR sky130_fd_sc_hd__decap_3
XTAP_TAPCELL_ROW_11_379 VGND VPWR sky130_fd_sc_hd__tapvpwrvgnd_1
XFILLER_114_209 VGND VGND VPWR VPWR sky130_fd_sc_hd__decap_3
XFILLER_47_9 VGND VGND VPWR VPWR sky130_fd_sc_hd__decap_3
XFILLER_5_399 VGND VGND VPWR VPWR sky130_fd_sc_hd__decap_3
XFILLER_110_404 VGND VGND VPWR VPWR sky130_fd_sc_hd__decap_3
XFILLER_1_561 VGND VGND VPWR VPWR sky130_fd_sc_hd__decap_3
XFILLER_3_24 VGND VGND VPWR VPWR sky130_fd_sc_hd__decap_3
XFILLER_68_307 VGND VGND VPWR VPWR sky130_fd_sc_hd__fill_1
XFILLER_95_104 VGND VGND VPWR VPWR sky130_fd_sc_hd__decap_3
XFILLER_96_638 VGND VGND VPWR VPWR sky130_fd_sc_hd__decap_3
XFILLER_1_594 VGND VGND VPWR VPWR sky130_fd_sc_hd__decap_3
XFILLER_3_57 VGND VGND VPWR VPWR sky130_fd_sc_hd__decap_3
XTAP_TAPCELL_ROW_112_1592 VGND VPWR sky130_fd_sc_hd__tapvpwrvgnd_1
XFILLER_36_215 VGND VGND VPWR VPWR sky130_fd_sc_hd__decap_3
XFILLER_64_557 VGND VGND VPWR VPWR sky130_fd_sc_hd__decap_3
XFILLER_51_218 VGND VGND VPWR VPWR sky130_fd_sc_hd__fill_2
XTAP_TAPCELL_ROW_67_1060 VGND VPWR sky130_fd_sc_hd__tapvpwrvgnd_1
XTAP_TAPCELL_ROW_19_479 VGND VPWR sky130_fd_sc_hd__tapvpwrvgnd_1
XFILLER_32_410 VGND VGND VPWR VPWR sky130_fd_sc_hd__decap_3
XFILLER_32_432 VGND VGND VPWR VPWR sky130_fd_sc_hd__decap_3
XFILLER_83_81 VGND VGND VPWR VPWR sky130_fd_sc_hd__decap_3
X_4890_ _5101_/A _4890_/B VGND VGND VPWR VPWR _4890_/Y sky130_fd_sc_hd__nor2_2
X_3910_ _6916_/Q _3926_/A2 _3913_/A2 _6780_/Q VGND VGND VPWR VPWR _3910_/X sky130_fd_sc_hd__a22o_2
XFILLER_20_616 VGND VGND VPWR VPWR sky130_fd_sc_hd__decap_3
X_3841_ _6845_/Q _3886_/A2 _3656_/Y _6830_/Q _3840_/X VGND VGND VPWR VPWR _3841_/X
+ sky130_fd_sc_hd__a221o_2
XFILLER_80_3 VGND VGND VPWR VPWR sky130_fd_sc_hd__decap_3
X_6560_ _6634_/A VGND VGND VPWR VPWR _6560_/Y sky130_fd_sc_hd__inv_2
X_3772_ _6854_/Q _3913_/B1 _3883_/B1 _6902_/Q _3771_/X VGND VGND VPWR VPWR _3772_/X
+ sky130_fd_sc_hd__a221o_2
XTAP_TAPCELL_ROW_30_611 VGND VPWR sky130_fd_sc_hd__tapvpwrvgnd_1
X_6491_ _6578_/A VGND VGND VPWR VPWR _6491_/Y sky130_fd_sc_hd__inv_2
XFILLER_8_193 VGND VGND VPWR VPWR sky130_fd_sc_hd__decap_3
X_5373_ _5373_/A0 _4792_/X _5386_/S VGND VGND VPWR VPWR _7146_/D sky130_fd_sc_hd__mux2_2
XFILLER_113_220 VGND VGND VPWR VPWR sky130_fd_sc_hd__decap_3
XFILLER_113_231 VGND VGND VPWR VPWR sky130_fd_sc_hd__decap_3
X_7112_ _7363_/CLK _7112_/D _6392_/Y VGND VGND VPWR VPWR _7112_/Q sky130_fd_sc_hd__dfrtp_2
Xoutput468 _5662_/A VGND VGND VPWR VPWR alu_result_out[14] sky130_fd_sc_hd__clkdlybuf4s25_1
X_4324_ _7039_/Q _4510_/S _4354_/B1 _7386_/Q VGND VGND VPWR VPWR _4324_/X sky130_fd_sc_hd__a22o_2
XFILLER_113_264 VGND VGND VPWR VPWR sky130_fd_sc_hd__decap_3
XFILLER_59_318 VGND VGND VPWR VPWR sky130_fd_sc_hd__decap_3
X_7043_ _7406_/CLK _7043_/D _6323_/Y VGND VGND VPWR VPWR _7043_/Q sky130_fd_sc_hd__dfrtp_2
Xoutput479 _5657_/A VGND VGND VPWR VPWR alu_result_out[24] sky130_fd_sc_hd__clkdlybuf4s25_1
XFILLER_86_137 VGND VGND VPWR VPWR sky130_fd_sc_hd__decap_3
XFILLER_87_638 VGND VGND VPWR VPWR sky130_fd_sc_hd__decap_3
X_4255_ _4251_/X _4254_/X _4327_/A VGND VGND VPWR VPWR _4256_/C sky130_fd_sc_hd__o21ai_2
X_4186_ _4186_/A _4636_/B VGND VGND VPWR VPWR _4634_/D sky130_fd_sc_hd__xnor2_2
XFILLER_27_204 VGND VGND VPWR VPWR sky130_fd_sc_hd__decap_3
XFILLER_95_671 VGND VGND VPWR VPWR sky130_fd_sc_hd__fill_1
XFILLER_95_682 VGND VGND VPWR VPWR sky130_fd_sc_hd__decap_3
XTAP_TAPCELL_ROW_38_711 VGND VPWR sky130_fd_sc_hd__tapvpwrvgnd_1
XFILLER_103_36 VGND VGND VPWR VPWR sky130_fd_sc_hd__decap_3
XFILLER_27_237 VGND VGND VPWR VPWR sky130_fd_sc_hd__decap_3
XFILLER_103_69 VGND VGND VPWR VPWR sky130_fd_sc_hd__decap_3
XFILLER_55_579 VGND VGND VPWR VPWR sky130_fd_sc_hd__decap_3
XFILLER_82_376 VGND VGND VPWR VPWR sky130_fd_sc_hd__decap_3
XFILLER_82_387 VGND VGND VPWR VPWR sky130_fd_sc_hd__decap_3
XFILLER_35_270 VGND VGND VPWR VPWR sky130_fd_sc_hd__decap_3
X_6827_ _6970_/CLK _6827_/D VGND VGND VPWR VPWR _6827_/Q sky130_fd_sc_hd__dfxtp_2
XFILLER_10_115 VGND VGND VPWR VPWR sky130_fd_sc_hd__decap_3
XFILLER_50_262 VGND VGND VPWR VPWR sky130_fd_sc_hd__decap_3
XFILLER_50_295 VGND VGND VPWR VPWR sky130_fd_sc_hd__decap_3
X_6758_ _6965_/CLK _6758_/D VGND VGND VPWR VPWR _6758_/Q sky130_fd_sc_hd__dfxtp_2
XFILLER_109_548 VGND VGND VPWR VPWR sky130_fd_sc_hd__decap_3
XFILLER_12_44 VGND VGND VPWR VPWR sky130_fd_sc_hd__decap_3
X_6689_ _7383_/CLK _6689_/D VGND VGND VPWR VPWR _6689_/Q sky130_fd_sc_hd__dfxtp_2
XFILLER_12_77 VGND VGND VPWR VPWR sky130_fd_sc_hd__decap_3
XFILLER_88_15 VGND VGND VPWR VPWR sky130_fd_sc_hd__decap_3
XFILLER_2_347 VGND VGND VPWR VPWR sky130_fd_sc_hd__decap_3
XFILLER_88_48 VGND VGND VPWR VPWR sky130_fd_sc_hd__fill_2
XFILLER_86_660 VGND VGND VPWR VPWR sky130_fd_sc_hd__decap_3
XFILLER_37_30 VGND VGND VPWR VPWR sky130_fd_sc_hd__decap_3
XFILLER_92_118 VGND VGND VPWR VPWR sky130_fd_sc_hd__decap_3
XFILLER_100_492 VGND VGND VPWR VPWR sky130_fd_sc_hd__decap_3
XFILLER_18_226 VGND VGND VPWR VPWR sky130_fd_sc_hd__decap_3
XFILLER_37_63 VGND VGND VPWR VPWR sky130_fd_sc_hd__decap_3
XFILLER_73_321 VGND VGND VPWR VPWR sky130_fd_sc_hd__decap_3
XFILLER_73_343 VGND VGND VPWR VPWR sky130_fd_sc_hd__decap_3
XFILLER_85_181 VGND VGND VPWR VPWR sky130_fd_sc_hd__decap_3
XFILLER_37_96 VGND VGND VPWR VPWR sky130_fd_sc_hd__decap_3
XFILLER_73_376 VGND VGND VPWR VPWR sky130_fd_sc_hd__decap_3
XTAP_TAPCELL_ROW_16_438 VGND VPWR sky130_fd_sc_hd__tapvpwrvgnd_1
XTAP_TAPCELL_ROW_16_449 VGND VPWR sky130_fd_sc_hd__tapvpwrvgnd_1
XFILLER_14_498 VGND VGND VPWR VPWR sky130_fd_sc_hd__decap_3
XFILLER_41_262 VGND VGND VPWR VPWR sky130_fd_sc_hd__decap_3
XFILLER_41_284 VGND VGND VPWR VPWR sky130_fd_sc_hd__decap_3
XFILLER_10_671 VGND VGND VPWR VPWR sky130_fd_sc_hd__decap_3
XFILLER_115_529 VGND VGND VPWR VPWR sky130_fd_sc_hd__decap_3
XFILLER_5_152 VGND VGND VPWR VPWR sky130_fd_sc_hd__decap_3
XFILLER_6_664 VGND VGND VPWR VPWR sky130_fd_sc_hd__decap_3
XTAP_TAPCELL_ROW_114_1621 VGND VPWR sky130_fd_sc_hd__tapvpwrvgnd_1
XFILLER_108_592 VGND VGND VPWR VPWR sky130_fd_sc_hd__decap_3
XFILLER_45_6 VGND VGND VPWR VPWR sky130_fd_sc_hd__decap_3
XFILLER_96_402 VGND VGND VPWR VPWR sky130_fd_sc_hd__decap_3
XFILLER_68_115 VGND VGND VPWR VPWR sky130_fd_sc_hd__decap_3
XFILLER_69_638 VGND VGND VPWR VPWR sky130_fd_sc_hd__decap_3
XFILLER_110_234 VGND VGND VPWR VPWR sky130_fd_sc_hd__fill_2
XFILLER_1_391 VGND VGND VPWR VPWR sky130_fd_sc_hd__fill_1
XFILLER_49_340 VGND VGND VPWR VPWR sky130_fd_sc_hd__decap_3
XFILLER_77_660 VGND VGND VPWR VPWR sky130_fd_sc_hd__decap_3
XFILLER_84_619 VGND VGND VPWR VPWR sky130_fd_sc_hd__decap_3
X_4040_ _4608_/B _4040_/B VGND VGND VPWR VPWR _4040_/Y sky130_fd_sc_hd__nor2_2
XFILLER_110_289 VGND VGND VPWR VPWR sky130_fd_sc_hd__decap_3
XFILLER_49_373 VGND VGND VPWR VPWR sky130_fd_sc_hd__decap_3
XFILLER_49_384 VGND VGND VPWR VPWR sky130_fd_sc_hd__decap_3
XFILLER_77_682 VGND VGND VPWR VPWR sky130_fd_sc_hd__decap_3
XFILLER_64_321 VGND VGND VPWR VPWR sky130_fd_sc_hd__decap_3
XFILLER_92_641 VGND VGND VPWR VPWR sky130_fd_sc_hd__decap_3
XFILLER_94_80 VGND VGND VPWR VPWR sky130_fd_sc_hd__decap_3
XFILLER_24_218 VGND VGND VPWR VPWR sky130_fd_sc_hd__decap_3
XFILLER_64_365 VGND VGND VPWR VPWR sky130_fd_sc_hd__decap_3
XFILLER_64_376 VGND VGND VPWR VPWR sky130_fd_sc_hd__decap_3
XFILLER_91_140 VGND VGND VPWR VPWR sky130_fd_sc_hd__decap_3
XFILLER_91_162 VGND VGND VPWR VPWR sky130_fd_sc_hd__decap_3
XFILLER_92_663 VGND VGND VPWR VPWR sky130_fd_sc_hd__decap_3
XFILLER_94_91 VGND VGND VPWR VPWR sky130_fd_sc_hd__decap_3
XFILLER_17_281 VGND VGND VPWR VPWR sky130_fd_sc_hd__decap_3
X_4942_ _6995_/Q _4960_/B _4677_/B _3403_/A VGND VGND VPWR VPWR _4943_/B sky130_fd_sc_hd__o211ai_2
XFILLER_20_424 VGND VGND VPWR VPWR sky130_fd_sc_hd__decap_3
XFILLER_32_262 VGND VGND VPWR VPWR sky130_fd_sc_hd__decap_3
XFILLER_60_582 VGND VGND VPWR VPWR sky130_fd_sc_hd__decap_3
X_6612_ _6644_/A VGND VGND VPWR VPWR _6612_/Y sky130_fd_sc_hd__inv_2
X_4873_ _4764_/B _4111_/B _4845_/A _5101_/A VGND VGND VPWR VPWR _4873_/X sky130_fd_sc_hd__o22a_2
XFILLER_20_446 VGND VGND VPWR VPWR sky130_fd_sc_hd__fill_2
X_3824_ _6965_/Q _3884_/A2 _3883_/A2 _6953_/Q _3823_/X VGND VGND VPWR VPWR _3824_/X
+ sky130_fd_sc_hd__a221o_2
X_6543_ _6548_/A VGND VGND VPWR VPWR _6543_/Y sky130_fd_sc_hd__inv_2
X_3755_ _6934_/Q _3768_/A2 _3767_/B1 _6886_/Q VGND VGND VPWR VPWR _3755_/X sky130_fd_sc_hd__a22o_2
X_6474_ _6638_/A VGND VGND VPWR VPWR _6474_/Y sky130_fd_sc_hd__inv_2
X_5425_ _5425_/A0 _3993_/X _5429_/S VGND VGND VPWR VPWR _7121_/D sky130_fd_sc_hd__mux2_2
XPHY_EDGE_ROW_12_Right_12 VGND VGND VPWR VPWR sky130_fd_sc_hd__decap_3
XTAP_TAPCELL_ROW_76_1159 VGND VPWR sky130_fd_sc_hd__tapvpwrvgnd_1
XFILLER_114_551 VGND VGND VPWR VPWR sky130_fd_sc_hd__decap_3
XFILLER_58_18 VGND VGND VPWR VPWR sky130_fd_sc_hd__decap_3
XFILLER_87_402 VGND VGND VPWR VPWR sky130_fd_sc_hd__decap_3
X_5356_ _5356_/A0 _3993_/X _5358_/S VGND VGND VPWR VPWR _7153_/D sky130_fd_sc_hd__mux2_2
XFILLER_99_251 VGND VGND VPWR VPWR sky130_fd_sc_hd__decap_3
XFILLER_114_584 VGND VGND VPWR VPWR sky130_fd_sc_hd__decap_3
XFILLER_114_595 VGND VGND VPWR VPWR sky130_fd_sc_hd__decap_3
XFILLER_87_435 VGND VGND VPWR VPWR sky130_fd_sc_hd__decap_3
X_4307_ _7224_/Q _4331_/A2 _4522_/S _7037_/Q VGND VGND VPWR VPWR _4307_/X sky130_fd_sc_hd__a22o_2
XFILLER_99_284 VGND VGND VPWR VPWR sky130_fd_sc_hd__decap_3
XFILLER_114_24 VGND VGND VPWR VPWR sky130_fd_sc_hd__decap_3
XFILLER_75_608 VGND VGND VPWR VPWR sky130_fd_sc_hd__decap_3
X_7026_ _7372_/CLK _7026_/D _6306_/Y VGND VGND VPWR VPWR _7026_/Q sky130_fd_sc_hd__dfrtp_2
X_4238_ _7067_/Q _4305_/B _4460_/A _4237_/X VGND VGND VPWR VPWR _4629_/B sky130_fd_sc_hd__o211ai_2
XFILLER_101_267 VGND VGND VPWR VPWR sky130_fd_sc_hd__decap_3
XFILLER_114_35 VGND VGND VPWR VPWR sky130_fd_sc_hd__decap_3
XFILLER_68_660 VGND VGND VPWR VPWR sky130_fd_sc_hd__decap_3
XFILLER_74_129 VGND VGND VPWR VPWR sky130_fd_sc_hd__decap_3
XFILLER_114_68 VGND VGND VPWR VPWR sky130_fd_sc_hd__decap_3
XFILLER_55_321 VGND VGND VPWR VPWR sky130_fd_sc_hd__decap_3
XFILLER_83_641 VGND VGND VPWR VPWR sky130_fd_sc_hd__decap_3
X_4169_ _4165_/X _4168_/X _4425_/A VGND VGND VPWR VPWR _4202_/A sky130_fd_sc_hd__o21a_2
XFILLER_15_207 VGND VGND VPWR VPWR sky130_fd_sc_hd__decap_3
XFILLER_55_354 VGND VGND VPWR VPWR sky130_fd_sc_hd__decap_3
XPHY_EDGE_ROW_21_Right_21 VGND VGND VPWR VPWR sky130_fd_sc_hd__decap_3
XTAP_TAPCELL_ROW_87_1299 VGND VPWR sky130_fd_sc_hd__tapvpwrvgnd_1
XFILLER_70_346 VGND VGND VPWR VPWR sky130_fd_sc_hd__decap_3
XFILLER_70_368 VGND VGND VPWR VPWR sky130_fd_sc_hd__decap_3
XFILLER_23_21 VGND VGND VPWR VPWR sky130_fd_sc_hd__decap_3
XTAP_TAPCELL_ROW_41_739 VGND VPWR sky130_fd_sc_hd__tapvpwrvgnd_1
XTAP_TAPCELL_ROW_13_408 VGND VPWR sky130_fd_sc_hd__tapvpwrvgnd_1
XFILLER_23_284 VGND VGND VPWR VPWR sky130_fd_sc_hd__decap_3
XFILLER_23_54 VGND VGND VPWR VPWR sky130_fd_sc_hd__fill_2
XFILLER_51_593 VGND VGND VPWR VPWR sky130_fd_sc_hd__decap_3
XFILLER_23_87 VGND VGND VPWR VPWR sky130_fd_sc_hd__decap_3
XFILLER_7_428 VGND VGND VPWR VPWR sky130_fd_sc_hd__decap_3
XPHY_EDGE_ROW_30_Right_30 VGND VGND VPWR VPWR sky130_fd_sc_hd__decap_3
XFILLER_99_47 VGND VGND VPWR VPWR sky130_fd_sc_hd__decap_3
XFILLER_109_367 VGND VGND VPWR VPWR sky130_fd_sc_hd__fill_2
XFILLER_99_69 VGND VGND VPWR VPWR sky130_fd_sc_hd__decap_3
XFILLER_2_100 VGND VGND VPWR VPWR sky130_fd_sc_hd__decap_3
XFILLER_3_634 VGND VGND VPWR VPWR sky130_fd_sc_hd__decap_3
XFILLER_2_133 VGND VGND VPWR VPWR sky130_fd_sc_hd__decap_3
XFILLER_2_144 VGND VGND VPWR VPWR sky130_fd_sc_hd__decap_3
XFILLER_3_667 VGND VGND VPWR VPWR sky130_fd_sc_hd__decap_3
XFILLER_105_573 VGND VGND VPWR VPWR sky130_fd_sc_hd__decap_3
XFILLER_105_595 VGND VGND VPWR VPWR sky130_fd_sc_hd__decap_3
XFILLER_78_413 VGND VGND VPWR VPWR sky130_fd_sc_hd__decap_3
XFILLER_78_424 VGND VGND VPWR VPWR sky130_fd_sc_hd__decap_3
XFILLER_66_619 VGND VGND VPWR VPWR sky130_fd_sc_hd__decap_3
XFILLER_78_446 VGND VGND VPWR VPWR sky130_fd_sc_hd__decap_3
XFILLER_78_468 VGND VGND VPWR VPWR sky130_fd_sc_hd__decap_3
XFILLER_59_671 VGND VGND VPWR VPWR sky130_fd_sc_hd__fill_1
XFILLER_59_682 VGND VGND VPWR VPWR sky130_fd_sc_hd__decap_3
XFILLER_93_438 VGND VGND VPWR VPWR sky130_fd_sc_hd__decap_3
XTAP_TAPCELL_ROW_49_839 VGND VPWR sky130_fd_sc_hd__tapvpwrvgnd_1
XFILLER_0_14 VGND VGND VPWR VPWR sky130_fd_sc_hd__decap_3
XFILLER_46_321 VGND VGND VPWR VPWR sky130_fd_sc_hd__decap_3
XFILLER_46_332 VGND VGND VPWR VPWR sky130_fd_sc_hd__decap_3
XFILLER_58_181 VGND VGND VPWR VPWR sky130_fd_sc_hd__fill_2
XFILLER_74_641 VGND VGND VPWR VPWR sky130_fd_sc_hd__decap_3
XFILLER_0_47 VGND VGND VPWR VPWR sky130_fd_sc_hd__decap_3
XFILLER_74_663 VGND VGND VPWR VPWR sky130_fd_sc_hd__decap_3
XFILLER_61_313 VGND VGND VPWR VPWR sky130_fd_sc_hd__decap_3
XTAP_TAPCELL_ROW_29_596 VGND VPWR sky130_fd_sc_hd__tapvpwrvgnd_1
XFILLER_61_346 VGND VGND VPWR VPWR sky130_fd_sc_hd__decap_3
XFILLER_64_83 VGND VGND VPWR VPWR sky130_fd_sc_hd__fill_1
XFILLER_9_12 VGND VGND VPWR VPWR sky130_fd_sc_hd__decap_3
XFILLER_14_251 VGND VGND VPWR VPWR sky130_fd_sc_hd__fill_1
XFILLER_14_262 VGND VGND VPWR VPWR sky130_fd_sc_hd__decap_3
XFILLER_42_560 VGND VGND VPWR VPWR sky130_fd_sc_hd__fill_1
XFILLER_9_45 VGND VGND VPWR VPWR sky130_fd_sc_hd__decap_3
XFILLER_9_78 VGND VGND VPWR VPWR sky130_fd_sc_hd__decap_3
X_3540_ _3502_/A _3502_/B _3485_/C VGND VGND VPWR VPWR _3540_/X sky130_fd_sc_hd__o21a_2
Xhold907 _6702_/Q VGND VGND VPWR VPWR hold907/X sky130_fd_sc_hd__dlygate4sd3_1
Xhold918 _6708_/Q VGND VGND VPWR VPWR hold918/X sky130_fd_sc_hd__dlygate4sd3_1
XFILLER_115_337 VGND VGND VPWR VPWR sky130_fd_sc_hd__decap_3
Xhold929 _7016_/Q VGND VGND VPWR VPWR _5624_/A sky130_fd_sc_hd__dlygate4sd3_1
X_3471_ _3545_/A _3545_/B VGND VGND VPWR VPWR _3505_/A sky130_fd_sc_hd__and2b_2
XFILLER_43_3 VGND VGND VPWR VPWR sky130_fd_sc_hd__decap_3
XFILLER_69_402 VGND VGND VPWR VPWR sky130_fd_sc_hd__decap_3
XFILLER_111_554 VGND VGND VPWR VPWR sky130_fd_sc_hd__decap_3
X_5072_ _5072_/A _5072_/B _5072_/C VGND VGND VPWR VPWR _5075_/B sky130_fd_sc_hd__and3_2
XFILLER_111_576 VGND VGND VPWR VPWR sky130_fd_sc_hd__decap_3
XFILLER_84_427 VGND VGND VPWR VPWR sky130_fd_sc_hd__decap_3
XFILLER_37_321 VGND VGND VPWR VPWR sky130_fd_sc_hd__decap_3
XFILLER_49_181 VGND VGND VPWR VPWR sky130_fd_sc_hd__decap_3
XFILLER_65_641 VGND VGND VPWR VPWR sky130_fd_sc_hd__decap_3
XFILLER_25_505 VGND VGND VPWR VPWR sky130_fd_sc_hd__decap_3
XFILLER_65_685 VGND VGND VPWR VPWR sky130_fd_sc_hd__decap_3
XFILLER_80_600 VGND VGND VPWR VPWR sky130_fd_sc_hd__decap_3
XFILLER_52_324 VGND VGND VPWR VPWR sky130_fd_sc_hd__decap_3
XFILLER_64_195 VGND VGND VPWR VPWR sky130_fd_sc_hd__fill_1
XFILLER_80_633 VGND VGND VPWR VPWR sky130_fd_sc_hd__decap_3
XFILLER_52_368 VGND VGND VPWR VPWR sky130_fd_sc_hd__fill_2
XFILLER_80_666 VGND VGND VPWR VPWR sky130_fd_sc_hd__decap_3
X_4925_ _4764_/B _4158_/A _4920_/A _5101_/A _4924_/X VGND VGND VPWR VPWR _4925_/X
+ sky130_fd_sc_hd__o221a_2
XFILLER_20_232 VGND VGND VPWR VPWR sky130_fd_sc_hd__fill_1
X_3807_ _6703_/Q _3889_/B1 _3883_/B1 _6881_/Q VGND VGND VPWR VPWR _3807_/X sky130_fd_sc_hd__a22o_2
X_6526_ _6647_/A VGND VGND VPWR VPWR _6526_/Y sky130_fd_sc_hd__inv_2
X_4787_ _4787_/A _4787_/B VGND VGND VPWR VPWR _4787_/Y sky130_fd_sc_hd__xnor2_2
XFILLER_109_24 VGND VGND VPWR VPWR sky130_fd_sc_hd__decap_3
XFILLER_114_9 VGND VGND VPWR VPWR sky130_fd_sc_hd__decap_3
XFILLER_4_409 VGND VGND VPWR VPWR sky130_fd_sc_hd__decap_3
X_3738_ _6740_/Q _3883_/A2 _3913_/B1 _6734_/Q _3737_/X VGND VGND VPWR VPWR _3738_/X
+ sky130_fd_sc_hd__a221o_2
XFILLER_109_57 VGND VGND VPWR VPWR sky130_fd_sc_hd__decap_3
X_6457_ _6584_/A VGND VGND VPWR VPWR _6457_/Y sky130_fd_sc_hd__inv_2
X_3669_ _6807_/Q _3759_/A2 _3767_/A2 _6717_/Q _3668_/X VGND VGND VPWR VPWR _3669_/X
+ sky130_fd_sc_hd__a221o_2
X_6388_ _6388_/A VGND VGND VPWR VPWR _6388_/Y sky130_fd_sc_hd__inv_2
XFILLER_0_615 VGND VGND VPWR VPWR sky130_fd_sc_hd__fill_1
XFILLER_0_626 VGND VGND VPWR VPWR sky130_fd_sc_hd__decap_3
XFILLER_102_510 VGND VGND VPWR VPWR sky130_fd_sc_hd__fill_2
XFILLER_0_648 VGND VGND VPWR VPWR sky130_fd_sc_hd__decap_3
XFILLER_102_576 VGND VGND VPWR VPWR sky130_fd_sc_hd__decap_3
XFILLER_48_619 VGND VGND VPWR VPWR sky130_fd_sc_hd__decap_3
XFILLER_75_405 VGND VGND VPWR VPWR sky130_fd_sc_hd__decap_3
XFILLER_87_287 VGND VGND VPWR VPWR sky130_fd_sc_hd__decap_3
XTAP_TAPCELL_ROW_89_1317 VGND VPWR sky130_fd_sc_hd__tapvpwrvgnd_1
XFILLER_18_21 VGND VGND VPWR VPWR sky130_fd_sc_hd__decap_3
XFILLER_18_32 VGND VGND VPWR VPWR sky130_fd_sc_hd__fill_1
XFILLER_68_490 VGND VGND VPWR VPWR sky130_fd_sc_hd__decap_3
X_7009_ _7234_/CLK _7009_/D _6289_/Y VGND VGND VPWR VPWR _7009_/Q sky130_fd_sc_hd__dfrtp_2
XFILLER_28_365 VGND VGND VPWR VPWR sky130_fd_sc_hd__fill_2
XFILLER_56_663 VGND VGND VPWR VPWR sky130_fd_sc_hd__decap_3
XFILLER_56_674 VGND VGND VPWR VPWR sky130_fd_sc_hd__decap_3
XTAP_TAPCELL_ROW_46_809 VGND VPWR sky130_fd_sc_hd__tapvpwrvgnd_1
XFILLER_16_527 VGND VGND VPWR VPWR sky130_fd_sc_hd__decap_3
XFILLER_43_302 VGND VGND VPWR VPWR sky130_fd_sc_hd__decap_3
XFILLER_43_335 VGND VGND VPWR VPWR sky130_fd_sc_hd__fill_1
XFILLER_71_644 VGND VGND VPWR VPWR sky130_fd_sc_hd__decap_3
XFILLER_55_195 VGND VGND VPWR VPWR sky130_fd_sc_hd__decap_3
XFILLER_70_121 VGND VGND VPWR VPWR sky130_fd_sc_hd__decap_3
XFILLER_34_64 VGND VGND VPWR VPWR sky130_fd_sc_hd__decap_3
XFILLER_70_165 VGND VGND VPWR VPWR sky130_fd_sc_hd__decap_3
XFILLER_71_688 VGND VGND VPWR VPWR sky130_fd_sc_hd__decap_3
XTAP_TAPCELL_ROW_54_897 VGND VPWR sky130_fd_sc_hd__tapvpwrvgnd_1
XTAP_TAPCELL_ROW_26_566 VGND VPWR sky130_fd_sc_hd__tapvpwrvgnd_1
XFILLER_11_221 VGND VGND VPWR VPWR sky130_fd_sc_hd__decap_3
XFILLER_34_97 VGND VGND VPWR VPWR sky130_fd_sc_hd__decap_3
XFILLER_51_390 VGND VGND VPWR VPWR sky130_fd_sc_hd__fill_2
XFILLER_11_243 VGND VGND VPWR VPWR sky130_fd_sc_hd__decap_3
XFILLER_109_131 VGND VGND VPWR VPWR sky130_fd_sc_hd__decap_3
XFILLER_11_276 VGND VGND VPWR VPWR sky130_fd_sc_hd__decap_3
XFILLER_11_287 VGND VGND VPWR VPWR sky130_fd_sc_hd__decap_3
XFILLER_7_225 VGND VGND VPWR VPWR sky130_fd_sc_hd__decap_3
XFILLER_109_164 VGND VGND VPWR VPWR sky130_fd_sc_hd__decap_3
XFILLER_50_52 VGND VGND VPWR VPWR sky130_fd_sc_hd__decap_3
XFILLER_50_85 VGND VGND VPWR VPWR sky130_fd_sc_hd__decap_3
XFILLER_3_420 VGND VGND VPWR VPWR sky130_fd_sc_hd__decap_3
XFILLER_112_307 VGND VGND VPWR VPWR sky130_fd_sc_hd__fill_1
XFILLER_3_464 VGND VGND VPWR VPWR sky130_fd_sc_hd__decap_3
XFILLER_59_72 VGND VGND VPWR VPWR sky130_fd_sc_hd__decap_3
XFILLER_38_129 VGND VGND VPWR VPWR sky130_fd_sc_hd__fill_1
XFILLER_47_641 VGND VGND VPWR VPWR sky130_fd_sc_hd__decap_3
XFILLER_66_449 VGND VGND VPWR VPWR sky130_fd_sc_hd__decap_3
XFILLER_75_60 VGND VGND VPWR VPWR sky130_fd_sc_hd__fill_2
XFILLER_81_419 VGND VGND VPWR VPWR sky130_fd_sc_hd__decap_3
XFILLER_93_279 VGND VGND VPWR VPWR sky130_fd_sc_hd__fill_1
XTAP_TAPCELL_ROW_109_1564 VGND VPWR sky130_fd_sc_hd__tapvpwrvgnd_1
XFILLER_46_162 VGND VGND VPWR VPWR sky130_fd_sc_hd__decap_3
XFILLER_47_685 VGND VGND VPWR VPWR sky130_fd_sc_hd__decap_3
XFILLER_62_622 VGND VGND VPWR VPWR sky130_fd_sc_hd__decap_3
XFILLER_74_493 VGND VGND VPWR VPWR sky130_fd_sc_hd__fill_1
XFILLER_62_666 VGND VGND VPWR VPWR sky130_fd_sc_hd__decap_3
XFILLER_61_154 VGND VGND VPWR VPWR sky130_fd_sc_hd__fill_1
XFILLER_61_187 VGND VGND VPWR VPWR sky130_fd_sc_hd__decap_3
XFILLER_30_541 VGND VGND VPWR VPWR sky130_fd_sc_hd__fill_1
XFILLER_91_81 VGND VGND VPWR VPWR sky130_fd_sc_hd__decap_3
X_5690_ _7351_/Q hold940/X _5708_/S VGND VGND VPWR VPWR _6695_/D sky130_fd_sc_hd__mux2_2
X_4710_ _7004_/Q _4801_/A VGND VGND VPWR VPWR _4775_/A sky130_fd_sc_hd__and2_2
X_4641_ _4920_/A _4379_/B _4640_/Y _4158_/A VGND VGND VPWR VPWR _4903_/B sky130_fd_sc_hd__o31a_2
X_7360_ _7360_/CLK _7360_/D _6640_/Y VGND VGND VPWR VPWR _7360_/Q sky130_fd_sc_hd__dfrtp_2
XFILLER_116_657 VGND VGND VPWR VPWR sky130_fd_sc_hd__decap_3
X_7291_ clkload3/A _7291_/D _6571_/Y VGND VGND VPWR VPWR _7291_/Q sky130_fd_sc_hd__dfrtp_2
Xhold704 _6841_/Q VGND VGND VPWR VPWR _6841_/D sky130_fd_sc_hd__dlygate4sd3_1
Xhold715 _6857_/Q VGND VGND VPWR VPWR _6857_/D sky130_fd_sc_hd__dlygate4sd3_1
Xhold726 _6954_/Q VGND VGND VPWR VPWR _6954_/D sky130_fd_sc_hd__dlygate4sd3_1
Xhold737 _6820_/Q VGND VGND VPWR VPWR _6820_/D sky130_fd_sc_hd__dlygate4sd3_1
X_6311_ _6660_/A VGND VGND VPWR VPWR _6311_/Y sky130_fd_sc_hd__inv_2
X_3523_ _3505_/A _3458_/Y _3505_/B _3506_/Y _3508_/A VGND VGND VPWR VPWR _3620_/A
+ sky130_fd_sc_hd__o311a_4
XFILLER_115_134 VGND VGND VPWR VPWR sky130_fd_sc_hd__decap_3
XFILLER_115_167 VGND VGND VPWR VPWR sky130_fd_sc_hd__fill_1
XFILLER_116_679 VGND VGND VPWR VPWR sky130_fd_sc_hd__decap_3
Xhold748 _6758_/Q VGND VGND VPWR VPWR _6758_/D sky130_fd_sc_hd__dlygate4sd3_1
Xhold759 _6731_/Q VGND VGND VPWR VPWR _6731_/D sky130_fd_sc_hd__dlygate4sd3_1
X_3454_ _7186_/Q _3996_/S _4534_/S _7031_/Q _3453_/X VGND VGND VPWR VPWR _3454_/X
+ sky130_fd_sc_hd__a221o_2
XTAP_TAPCELL_ROW_73_1129 VGND VPWR sky130_fd_sc_hd__tapvpwrvgnd_1
XFILLER_115_178 VGND VGND VPWR VPWR sky130_fd_sc_hd__decap_3
XFILLER_111_340 VGND VGND VPWR VPWR sky130_fd_sc_hd__decap_3
XFILLER_69_243 VGND VGND VPWR VPWR sky130_fd_sc_hd__decap_3
XFILLER_97_541 VGND VGND VPWR VPWR sky130_fd_sc_hd__fill_2
X_3385_ _6983_/Q _5130_/A VGND VGND VPWR VPWR _3385_/Y sky130_fd_sc_hd__nor2_2
XFILLER_69_287 VGND VGND VPWR VPWR sky130_fd_sc_hd__decap_3
X_5124_ _3746_/B _3900_/Y _4677_/B VGND VGND VPWR VPWR _5125_/B sky130_fd_sc_hd__a21o_2
XFILLER_57_449 VGND VGND VPWR VPWR sky130_fd_sc_hd__fill_2
XFILLER_84_213 VGND VGND VPWR VPWR sky130_fd_sc_hd__decap_3
XFILLER_84_235 VGND VGND VPWR VPWR sky130_fd_sc_hd__decap_3
X_5055_ _5146_/B1 _5049_/X _5053_/Y _5054_/Y _4369_/A VGND VGND VPWR VPWR _5055_/X
+ sky130_fd_sc_hd__a221o_2
XFILLER_38_663 VGND VGND VPWR VPWR sky130_fd_sc_hd__decap_3
XFILLER_72_408 VGND VGND VPWR VPWR sky130_fd_sc_hd__decap_3
XFILLER_1_90 VGND VGND VPWR VPWR sky130_fd_sc_hd__decap_3
XFILLER_111_47 VGND VGND VPWR VPWR sky130_fd_sc_hd__decap_3
XFILLER_25_346 VGND VGND VPWR VPWR sky130_fd_sc_hd__decap_3
XFILLER_37_195 VGND VGND VPWR VPWR sky130_fd_sc_hd__decap_3
XFILLER_53_644 VGND VGND VPWR VPWR sky130_fd_sc_hd__decap_3
XFILLER_80_430 VGND VGND VPWR VPWR sky130_fd_sc_hd__decap_3
XFILLER_80_452 VGND VGND VPWR VPWR sky130_fd_sc_hd__decap_3
XTAP_TAPCELL_ROW_84_1258 VGND VPWR sky130_fd_sc_hd__tapvpwrvgnd_1
XFILLER_111_69 VGND VGND VPWR VPWR sky130_fd_sc_hd__decap_3
XFILLER_13_508 VGND VGND VPWR VPWR sky130_fd_sc_hd__fill_2
XFILLER_71_18 VGND VGND VPWR VPWR sky130_fd_sc_hd__decap_3
XFILLER_80_463 VGND VGND VPWR VPWR sky130_fd_sc_hd__decap_3
XFILLER_40_327 VGND VGND VPWR VPWR sky130_fd_sc_hd__decap_3
XFILLER_52_187 VGND VGND VPWR VPWR sky130_fd_sc_hd__fill_1
X_4908_ _4908_/A _4908_/B VGND VGND VPWR VPWR _4909_/C sky130_fd_sc_hd__nor2_2
XTAP_TAPCELL_ROW_23_525 VGND VPWR sky130_fd_sc_hd__tapvpwrvgnd_1
XTAP_TAPCELL_ROW_51_867 VGND VPWR sky130_fd_sc_hd__tapvpwrvgnd_1
X_4839_ _4916_/A _4916_/B _4634_/Y VGND VGND VPWR VPWR _4903_/C sky130_fd_sc_hd__a21o_2
XFILLER_107_613 VGND VGND VPWR VPWR sky130_fd_sc_hd__decap_3
XFILLER_4_206 VGND VGND VPWR VPWR sky130_fd_sc_hd__decap_3
XFILLER_106_123 VGND VGND VPWR VPWR sky130_fd_sc_hd__decap_3
XFILLER_107_635 VGND VGND VPWR VPWR sky130_fd_sc_hd__decap_3
X_6509_ _6576_/A VGND VGND VPWR VPWR _6509_/Y sky130_fd_sc_hd__inv_2
XFILLER_107_668 VGND VGND VPWR VPWR sky130_fd_sc_hd__decap_3
XFILLER_107_679 VGND VGND VPWR VPWR sky130_fd_sc_hd__decap_3
XFILLER_20_55 VGND VGND VPWR VPWR sky130_fd_sc_hd__decap_3
XTAP_TAPCELL_ROW_95_1387 VGND VPWR sky130_fd_sc_hd__tapvpwrvgnd_1
XFILLER_0_412 VGND VGND VPWR VPWR sky130_fd_sc_hd__decap_3
XFILLER_106_167 VGND VGND VPWR VPWR sky130_fd_sc_hd__decap_3
XFILLER_20_88 VGND VGND VPWR VPWR sky130_fd_sc_hd__decap_3
XFILLER_20_99 VGND VGND VPWR VPWR sky130_fd_sc_hd__decap_3
XFILLER_96_26 VGND VGND VPWR VPWR sky130_fd_sc_hd__fill_2
XFILLER_88_530 VGND VGND VPWR VPWR sky130_fd_sc_hd__fill_2
XFILLER_96_59 VGND VGND VPWR VPWR sky130_fd_sc_hd__decap_3
XFILLER_0_467 VGND VGND VPWR VPWR sky130_fd_sc_hd__decap_3
XFILLER_102_362 VGND VGND VPWR VPWR sky130_fd_sc_hd__fill_2
XFILLER_102_373 VGND VGND VPWR VPWR sky130_fd_sc_hd__decap_3
XFILLER_48_416 VGND VGND VPWR VPWR sky130_fd_sc_hd__decap_3
XFILLER_29_75 VGND VGND VPWR VPWR sky130_fd_sc_hd__decap_3
XTAP_TAPCELL_ROW_59_956 VGND VPWR sky130_fd_sc_hd__tapvpwrvgnd_1
XFILLER_45_30 VGND VGND VPWR VPWR sky130_fd_sc_hd__decap_3
XFILLER_90_216 VGND VGND VPWR VPWR sky130_fd_sc_hd__fill_2
XFILLER_90_238 VGND VGND VPWR VPWR sky130_fd_sc_hd__decap_3
Xplace408 _3562_/A VGND VGND VPWR VPWR _4505_/S sky130_fd_sc_hd__buf_2
Xplace419 _4268_/A2 VGND VGND VPWR VPWR _3962_/S sky130_fd_sc_hd__buf_2
XTAP_TAPCELL_ROW_3_283 VGND VPWR sky130_fd_sc_hd__tapvpwrvgnd_1
XFILLER_28_195 VGND VGND VPWR VPWR sky130_fd_sc_hd__fill_1
XFILLER_45_63 VGND VGND VPWR VPWR sky130_fd_sc_hd__decap_3
XFILLER_45_74 VGND VGND VPWR VPWR sky130_fd_sc_hd__decap_3
XFILLER_71_441 VGND VGND VPWR VPWR sky130_fd_sc_hd__fill_2
XFILLER_44_688 VGND VGND VPWR VPWR sky130_fd_sc_hd__decap_3
XFILLER_43_198 VGND VGND VPWR VPWR sky130_fd_sc_hd__decap_3
XTAP_TAPCELL_ROW_104_1494 VGND VPWR sky130_fd_sc_hd__tapvpwrvgnd_1
XFILLER_101_80 VGND VGND VPWR VPWR sky130_fd_sc_hd__decap_3
XFILLER_8_501 VGND VGND VPWR VPWR sky130_fd_sc_hd__decap_3
XFILLER_77_9 VGND VGND VPWR VPWR sky130_fd_sc_hd__decap_3
XFILLER_6_24 VGND VGND VPWR VPWR sky130_fd_sc_hd__decap_3
XFILLER_8_589 VGND VGND VPWR VPWR sky130_fd_sc_hd__fill_1
XANTENNA_6 _7359_/Q VGND VGND VPWR VPWR sky130_fd_sc_hd__diode_2
XFILLER_6_35 VGND VGND VPWR VPWR sky130_fd_sc_hd__decap_3
XFILLER_6_68 VGND VGND VPWR VPWR sky130_fd_sc_hd__decap_3
XFILLER_112_115 VGND VGND VPWR VPWR sky130_fd_sc_hd__decap_3
XFILLER_113_638 VGND VGND VPWR VPWR sky130_fd_sc_hd__decap_3
XFILLER_106_690 VGND VGND VPWR VPWR sky130_fd_sc_hd__fill_2
XFILLER_112_159 VGND VGND VPWR VPWR sky130_fd_sc_hd__decap_3
XFILLER_98_349 VGND VGND VPWR VPWR sky130_fd_sc_hd__decap_3
XFILLER_79_585 VGND VGND VPWR VPWR sky130_fd_sc_hd__decap_3
XFILLER_39_449 VGND VGND VPWR VPWR sky130_fd_sc_hd__decap_3
XFILLER_79_596 VGND VGND VPWR VPWR sky130_fd_sc_hd__decap_3
XFILLER_94_533 VGND VGND VPWR VPWR sky130_fd_sc_hd__decap_3
XFILLER_54_419 VGND VGND VPWR VPWR sky130_fd_sc_hd__fill_1
XFILLER_66_268 VGND VGND VPWR VPWR sky130_fd_sc_hd__fill_1
XFILLER_94_566 VGND VGND VPWR VPWR sky130_fd_sc_hd__decap_3
XFILLER_19_184 VGND VGND VPWR VPWR sky130_fd_sc_hd__fill_1
XFILLER_62_441 VGND VGND VPWR VPWR sky130_fd_sc_hd__decap_3
XFILLER_81_249 VGND VGND VPWR VPWR sky130_fd_sc_hd__decap_3
X_6860_ _6971_/CLK _6860_/D VGND VGND VPWR VPWR _6860_/Q sky130_fd_sc_hd__dfxtp_2
XFILLER_34_176 VGND VGND VPWR VPWR sky130_fd_sc_hd__decap_3
XFILLER_50_603 VGND VGND VPWR VPWR sky130_fd_sc_hd__decap_3
X_6791_ _7392_/CLK _6791_/D VGND VGND VPWR VPWR _6791_/Q sky130_fd_sc_hd__dfxtp_2
XFILLER_22_327 VGND VGND VPWR VPWR sky130_fd_sc_hd__decap_3
XFILLER_22_349 VGND VGND VPWR VPWR sky130_fd_sc_hd__decap_3
XFILLER_50_636 VGND VGND VPWR VPWR sky130_fd_sc_hd__decap_3
XFILLER_50_669 VGND VGND VPWR VPWR sky130_fd_sc_hd__decap_3
XFILLER_30_371 VGND VGND VPWR VPWR sky130_fd_sc_hd__decap_3
X_7412_ _7412_/A VGND VGND VPWR VPWR _7412_/X sky130_fd_sc_hd__buf_2
X_4624_ _4624_/A _4624_/B VGND VGND VPWR VPWR _4624_/X sky130_fd_sc_hd__and2_2
XPHY_EDGE_ROW_6_Right_6 VGND VGND VPWR VPWR sky130_fd_sc_hd__decap_3
XFILLER_116_421 VGND VGND VPWR VPWR sky130_fd_sc_hd__decap_3
X_7343_ _7387_/CLK _7343_/D _6623_/Y VGND VGND VPWR VPWR _7343_/Q sky130_fd_sc_hd__dfrtp_2
XFILLER_116_465 VGND VGND VPWR VPWR sky130_fd_sc_hd__decap_3
X_3506_ _3544_/A _3506_/B VGND VGND VPWR VPWR _3506_/Y sky130_fd_sc_hd__nand2_2
XFILLER_103_104 VGND VGND VPWR VPWR sky130_fd_sc_hd__decap_3
XFILLER_104_616 VGND VGND VPWR VPWR sky130_fd_sc_hd__decap_3
X_7274_ _7368_/CLK _7274_/D _6554_/Y VGND VGND VPWR VPWR _7274_/Q sky130_fd_sc_hd__dfrtp_2
X_4486_ _4486_/A0 _7304_/Q _4493_/S VGND VGND VPWR VPWR _7336_/D sky130_fd_sc_hd__mux2_2
XFILLER_89_349 VGND VGND VPWR VPWR sky130_fd_sc_hd__decap_3
Xhold589 _6922_/Q VGND VGND VPWR VPWR _6922_/D sky130_fd_sc_hd__dlygate4sd3_1
XFILLER_106_47 VGND VGND VPWR VPWR sky130_fd_sc_hd__decap_3
XFILLER_112_660 VGND VGND VPWR VPWR sky130_fd_sc_hd__decap_3
XFILLER_66_18 VGND VGND VPWR VPWR sky130_fd_sc_hd__decap_3
X_3368_ _3342_/B _5294_/A _3310_/Y _4697_/A VGND VGND VPWR VPWR _3368_/Y sky130_fd_sc_hd__a211oi_4
XFILLER_111_181 VGND VGND VPWR VPWR sky130_fd_sc_hd__decap_3
XFILLER_57_213 VGND VGND VPWR VPWR sky130_fd_sc_hd__fill_2
XFILLER_66_29 VGND VGND VPWR VPWR sky130_fd_sc_hd__decap_3
XFILLER_85_544 VGND VGND VPWR VPWR sky130_fd_sc_hd__decap_3
Xhold1201 _7150_/Q VGND VGND VPWR VPWR _5365_/A0 sky130_fd_sc_hd__dlygate4sd3_1
Xhold1212 _7337_/Q VGND VGND VPWR VPWR _4484_/A0 sky130_fd_sc_hd__dlygate4sd3_1
Xhold1223 _7173_/Q VGND VGND VPWR VPWR _5315_/A0 sky130_fd_sc_hd__dlygate4sd3_1
X_5107_ _5156_/S _6985_/D _5105_/X _5106_/X VGND VGND VPWR VPWR _5107_/X sky130_fd_sc_hd__o22a_2
XFILLER_45_408 VGND VGND VPWR VPWR sky130_fd_sc_hd__decap_3
XFILLER_57_257 VGND VGND VPWR VPWR sky130_fd_sc_hd__decap_3
X_3299_ _3353_/A _6979_/Q _3327_/A VGND VGND VPWR VPWR _3328_/A sky130_fd_sc_hd__o21a_2
XFILLER_26_600 VGND VGND VPWR VPWR sky130_fd_sc_hd__fill_2
XFILLER_85_599 VGND VGND VPWR VPWR sky130_fd_sc_hd__decap_3
X_5038_ _5038_/A _5038_/B VGND VGND VPWR VPWR _5038_/X sky130_fd_sc_hd__xor2_2
XTAP_TAPCELL_ROW_56_926 VGND VPWR sky130_fd_sc_hd__tapvpwrvgnd_1
XFILLER_72_249 VGND VGND VPWR VPWR sky130_fd_sc_hd__decap_3
XTAP_TAPCELL_ROW_0_253 VGND VPWR sky130_fd_sc_hd__tapvpwrvgnd_1
XTAP_TAPCELL_ROW_0_242 VGND VPWR sky130_fd_sc_hd__tapvpwrvgnd_1
XFILLER_25_143 VGND VGND VPWR VPWR sky130_fd_sc_hd__decap_3
XFILLER_25_154 VGND VGND VPWR VPWR sky130_fd_sc_hd__decap_3
XFILLER_41_614 VGND VGND VPWR VPWR sky130_fd_sc_hd__fill_2
XFILLER_53_452 VGND VGND VPWR VPWR sky130_fd_sc_hd__fill_1
XFILLER_53_474 VGND VGND VPWR VPWR sky130_fd_sc_hd__decap_3
XFILLER_15_33 VGND VGND VPWR VPWR sky130_fd_sc_hd__decap_3
XFILLER_15_66 VGND VGND VPWR VPWR sky130_fd_sc_hd__decap_3
XFILLER_40_102 VGND VGND VPWR VPWR sky130_fd_sc_hd__decap_3
XFILLER_41_636 VGND VGND VPWR VPWR sky130_fd_sc_hd__decap_3
X_6989_ _7402_/CLK _6989_/D _6269_/Y VGND VGND VPWR VPWR _6989_/Q sky130_fd_sc_hd__dfrtp_2
XTAP_TAPCELL_ROW_36_683 VGND VPWR sky130_fd_sc_hd__tapvpwrvgnd_1
XFILLER_21_393 VGND VGND VPWR VPWR sky130_fd_sc_hd__decap_3
XFILLER_31_21 VGND VGND VPWR VPWR sky130_fd_sc_hd__decap_3
XFILLER_31_43 VGND VGND VPWR VPWR sky130_fd_sc_hd__decap_3
XTAP_TAPCELL_ROW_97_1416 VGND VPWR sky130_fd_sc_hd__tapvpwrvgnd_1
XFILLER_110_3 VGND VGND VPWR VPWR sky130_fd_sc_hd__decap_3
XFILLER_31_87 VGND VGND VPWR VPWR sky130_fd_sc_hd__fill_1
XFILLER_107_487 VGND VGND VPWR VPWR sky130_fd_sc_hd__fill_2
XFILLER_107_498 VGND VGND VPWR VPWR sky130_fd_sc_hd__decap_3
XTAP_TAPCELL_ROW_8_353 VGND VPWR sky130_fd_sc_hd__tapvpwrvgnd_1
XTAP_TAPCELL_ROW_8_342 VGND VPWR sky130_fd_sc_hd__tapvpwrvgnd_1
XFILLER_103_671 VGND VGND VPWR VPWR sky130_fd_sc_hd__fill_1
XFILLER_110_619 VGND VGND VPWR VPWR sky130_fd_sc_hd__decap_3
XFILLER_102_181 VGND VGND VPWR VPWR sky130_fd_sc_hd__fill_1
XFILLER_103_682 VGND VGND VPWR VPWR sky130_fd_sc_hd__fill_2
XFILLER_76_533 VGND VGND VPWR VPWR sky130_fd_sc_hd__decap_3
XFILLER_88_371 VGND VGND VPWR VPWR sky130_fd_sc_hd__fill_2
XFILLER_102_192 VGND VGND VPWR VPWR sky130_fd_sc_hd__decap_3
XFILLER_48_279 VGND VGND VPWR VPWR sky130_fd_sc_hd__decap_3
XFILLER_56_51 VGND VGND VPWR VPWR sky130_fd_sc_hd__decap_3
XFILLER_91_514 VGND VGND VPWR VPWR sky130_fd_sc_hd__decap_3
XFILLER_17_633 VGND VGND VPWR VPWR sky130_fd_sc_hd__fill_2
XFILLER_17_655 VGND VGND VPWR VPWR sky130_fd_sc_hd__decap_3
XFILLER_44_430 VGND VGND VPWR VPWR sky130_fd_sc_hd__decap_3
XFILLER_56_95 VGND VGND VPWR VPWR sky130_fd_sc_hd__fill_2
XTAP_TAPCELL_ROW_106_1523 VGND VPWR sky130_fd_sc_hd__tapvpwrvgnd_1
XFILLER_32_603 VGND VGND VPWR VPWR sky130_fd_sc_hd__decap_3
XFILLER_16_176 VGND VGND VPWR VPWR sky130_fd_sc_hd__decap_3
XFILLER_31_113 VGND VGND VPWR VPWR sky130_fd_sc_hd__decap_3
XFILLER_72_61 VGND VGND VPWR VPWR sky130_fd_sc_hd__decap_3
XFILLER_12_371 VGND VGND VPWR VPWR sky130_fd_sc_hd__decap_3
XFILLER_8_320 VGND VGND VPWR VPWR sky130_fd_sc_hd__fill_2
XPHY_EDGE_ROW_59_Right_59 VGND VGND VPWR VPWR sky130_fd_sc_hd__decap_3
XFILLER_40_691 VGND VGND VPWR VPWR sky130_fd_sc_hd__fill_1
XFILLER_75_6 VGND VGND VPWR VPWR sky130_fd_sc_hd__decap_3
XFILLER_8_375 VGND VGND VPWR VPWR sky130_fd_sc_hd__decap_3
X_4340_ _7223_/Q _3377_/X _4338_/X _4339_/X VGND VGND VPWR VPWR _4340_/X sky130_fd_sc_hd__a211o_2
XFILLER_98_102 VGND VGND VPWR VPWR sky130_fd_sc_hd__decap_3
XFILLER_113_435 VGND VGND VPWR VPWR sky130_fd_sc_hd__decap_3
XFILLER_4_581 VGND VGND VPWR VPWR sky130_fd_sc_hd__decap_3
X_4271_ _4271_/A _4271_/B _4271_/C _4270_/Y VGND VGND VPWR VPWR _4271_/X sky130_fd_sc_hd__or4b_2
XFILLER_99_647 VGND VGND VPWR VPWR sky130_fd_sc_hd__decap_3
XFILLER_100_107 VGND VGND VPWR VPWR sky130_fd_sc_hd__decap_3
XFILLER_67_511 VGND VGND VPWR VPWR sky130_fd_sc_hd__decap_3
XPHY_EDGE_ROW_68_Right_68 VGND VGND VPWR VPWR sky130_fd_sc_hd__decap_3
XFILLER_39_235 VGND VGND VPWR VPWR sky130_fd_sc_hd__decap_3
XFILLER_54_227 VGND VGND VPWR VPWR sky130_fd_sc_hd__decap_3
XFILLER_82_525 VGND VGND VPWR VPWR sky130_fd_sc_hd__decap_3
XFILLER_94_385 VGND VGND VPWR VPWR sky130_fd_sc_hd__decap_3
XFILLER_47_290 VGND VGND VPWR VPWR sky130_fd_sc_hd__decap_3
X_6912_ _6944_/CLK _6912_/D VGND VGND VPWR VPWR _6912_/Q sky130_fd_sc_hd__dfxtp_2
XFILLER_35_452 VGND VGND VPWR VPWR sky130_fd_sc_hd__fill_2
X_6843_ _6970_/CLK _6843_/D VGND VGND VPWR VPWR _6843_/Q sky130_fd_sc_hd__dfxtp_2
XFILLER_62_271 VGND VGND VPWR VPWR sky130_fd_sc_hd__decap_3
XTAP_TAPCELL_ROW_81_1228 VGND VPWR sky130_fd_sc_hd__tapvpwrvgnd_1
XFILLER_22_135 VGND VGND VPWR VPWR sky130_fd_sc_hd__fill_1
XFILLER_50_455 VGND VGND VPWR VPWR sky130_fd_sc_hd__decap_3
XFILLER_50_466 VGND VGND VPWR VPWR sky130_fd_sc_hd__fill_1
X_6774_ _6971_/CLK _6774_/D VGND VGND VPWR VPWR _6774_/Q sky130_fd_sc_hd__dfxtp_2
XTAP_TAPCELL_ROW_33_653 VGND VPWR sky130_fd_sc_hd__tapvpwrvgnd_1
XTAP_TAPCELL_ROW_33_642 VGND VPWR sky130_fd_sc_hd__tapvpwrvgnd_1
XPHY_EDGE_ROW_77_Right_77 VGND VGND VPWR VPWR sky130_fd_sc_hd__decap_3
XFILLER_50_477 VGND VGND VPWR VPWR sky130_fd_sc_hd__decap_3
XFILLER_50_488 VGND VGND VPWR VPWR sky130_fd_sc_hd__decap_3
X_5725_ _7368_/Q hold916/X _5737_/S VGND VGND VPWR VPWR _6712_/D sky130_fd_sc_hd__mux2_2
XTAP_TAPCELL_ROW_61_984 VGND VPWR sky130_fd_sc_hd__tapvpwrvgnd_1
X_5656_ _5656_/A _5656_/B _5656_/C VGND VGND VPWR VPWR _5665_/C sky130_fd_sc_hd__nor3_2
XFILLER_108_218 VGND VGND VPWR VPWR sky130_fd_sc_hd__decap_3
XFILLER_116_240 VGND VGND VPWR VPWR sky130_fd_sc_hd__decap_3
X_5587_ _5587_/A _5587_/B VGND VGND VPWR VPWR _7034_/D sky130_fd_sc_hd__and2_2
XFILLER_116_262 VGND VGND VPWR VPWR sky130_fd_sc_hd__decap_3
XFILLER_89_102 VGND VGND VPWR VPWR sky130_fd_sc_hd__decap_3
XFILLER_89_113 VGND VGND VPWR VPWR sky130_fd_sc_hd__fill_2
X_7326_ _7360_/CLK _7326_/D _6606_/Y VGND VGND VPWR VPWR _7326_/Q sky130_fd_sc_hd__dfrtp_2
XFILLER_104_424 VGND VGND VPWR VPWR sky130_fd_sc_hd__fill_2
XFILLER_104_435 VGND VGND VPWR VPWR sky130_fd_sc_hd__fill_2
XFILLER_116_295 VGND VGND VPWR VPWR sky130_fd_sc_hd__decap_3
XFILLER_7_9 VGND VGND VPWR VPWR sky130_fd_sc_hd__decap_3
XFILLER_89_146 VGND VGND VPWR VPWR sky130_fd_sc_hd__decap_3
X_7257_ clkload8/A _7257_/D _6537_/Y VGND VGND VPWR VPWR _7257_/Q sky130_fd_sc_hd__dfrtp_2
X_4469_ _7009_/Q _4467_/A _4469_/A3 _4468_/X VGND VGND VPWR VPWR _4469_/X sky130_fd_sc_hd__a31o_2
XTAP_TAPCELL_ROW_92_1357 VGND VPWR sky130_fd_sc_hd__tapvpwrvgnd_1
XFILLER_58_500 VGND VGND VPWR VPWR sky130_fd_sc_hd__decap_3
XFILLER_89_179 VGND VGND VPWR VPWR sky130_fd_sc_hd__decap_3
XTAP_TAPCELL_ROW_5_312 VGND VPWR sky130_fd_sc_hd__tapvpwrvgnd_1
XPHY_EDGE_ROW_86_Right_86 VGND VGND VPWR VPWR sky130_fd_sc_hd__decap_3
X_7188_ clkload6/A _7188_/D _6468_/Y VGND VGND VPWR VPWR _7188_/Q sky130_fd_sc_hd__dfrtp_2
XFILLER_100_641 VGND VGND VPWR VPWR sky130_fd_sc_hd__decap_3
XFILLER_100_663 VGND VGND VPWR VPWR sky130_fd_sc_hd__decap_3
XFILLER_58_566 VGND VGND VPWR VPWR sky130_fd_sc_hd__decap_3
Xhold1020 _7027_/Q VGND VGND VPWR VPWR _5600_/A sky130_fd_sc_hd__dlygate4sd3_1
Xhold1031 _7192_/Q VGND VGND VPWR VPWR _5276_/A0 sky130_fd_sc_hd__dlygate4sd3_1
Xhold1042 _7213_/Q VGND VGND VPWR VPWR _5234_/A0 sky130_fd_sc_hd__dlygate4sd3_1
XFILLER_73_503 VGND VGND VPWR VPWR sky130_fd_sc_hd__fill_1
Xhold1053 _7267_/Q VGND VGND VPWR VPWR _4914_/A0 sky130_fd_sc_hd__dlygate4sd3_1
Xhold1064 _7388_/Q VGND VGND VPWR VPWR _3833_/A0 sky130_fd_sc_hd__dlygate4sd3_1
Xhold1075 _7274_/Q VGND VGND VPWR VPWR _4793_/A0 sky130_fd_sc_hd__dlygate4sd3_1
XFILLER_26_21 VGND VGND VPWR VPWR sky130_fd_sc_hd__decap_3
XFILLER_45_249 VGND VGND VPWR VPWR sky130_fd_sc_hd__decap_3
XFILLER_73_569 VGND VGND VPWR VPWR sky130_fd_sc_hd__decap_3
Xhold1086 _7309_/Q VGND VGND VPWR VPWR _4542_/A sky130_fd_sc_hd__dlygate4sd3_1
Xhold1097 _7335_/Q VGND VGND VPWR VPWR _4488_/A0 sky130_fd_sc_hd__dlygate4sd3_1
XFILLER_14_603 VGND VGND VPWR VPWR sky130_fd_sc_hd__fill_2
XFILLER_26_474 VGND VGND VPWR VPWR sky130_fd_sc_hd__fill_2
XFILLER_26_54 VGND VGND VPWR VPWR sky130_fd_sc_hd__decap_3
XFILLER_60_208 VGND VGND VPWR VPWR sky130_fd_sc_hd__fill_2
XFILLER_13_113 VGND VGND VPWR VPWR sky130_fd_sc_hd__decap_3
XPHY_EDGE_ROW_95_Right_95 VGND VGND VPWR VPWR sky130_fd_sc_hd__decap_3
XTAP_TAPCELL_ROW_101_1464 VGND VPWR sky130_fd_sc_hd__tapvpwrvgnd_1
XFILLER_22_691 VGND VGND VPWR VPWR sky130_fd_sc_hd__fill_1
XFILLER_5_345 VGND VGND VPWR VPWR sky130_fd_sc_hd__decap_3
XFILLER_107_273 VGND VGND VPWR VPWR sky130_fd_sc_hd__decap_3
XPHY_EDGE_ROW_39_Left_156 VGND VGND VPWR VPWR sky130_fd_sc_hd__decap_3
XFILLER_107_284 VGND VGND VPWR VPWR sky130_fd_sc_hd__decap_3
XFILLER_3_36 VGND VGND VPWR VPWR sky130_fd_sc_hd__decap_3
XFILLER_96_617 VGND VGND VPWR VPWR sky130_fd_sc_hd__decap_3
XFILLER_107_90 VGND VGND VPWR VPWR sky130_fd_sc_hd__decap_3
XFILLER_1_573 VGND VGND VPWR VPWR sky130_fd_sc_hd__fill_1
XFILLER_3_69 VGND VGND VPWR VPWR sky130_fd_sc_hd__decap_3
XFILLER_89_691 VGND VGND VPWR VPWR sky130_fd_sc_hd__fill_1
XFILLER_95_116 VGND VGND VPWR VPWR sky130_fd_sc_hd__decap_3
XFILLER_95_138 VGND VGND VPWR VPWR sky130_fd_sc_hd__decap_3
XTAP_TAPCELL_ROW_112_1593 VGND VPWR sky130_fd_sc_hd__tapvpwrvgnd_1
XFILLER_49_566 VGND VGND VPWR VPWR sky130_fd_sc_hd__decap_3
XFILLER_88_190 VGND VGND VPWR VPWR sky130_fd_sc_hd__decap_3
XFILLER_91_311 VGND VGND VPWR VPWR sky130_fd_sc_hd__decap_3
XFILLER_36_227 VGND VGND VPWR VPWR sky130_fd_sc_hd__decap_3
XFILLER_64_536 VGND VGND VPWR VPWR sky130_fd_sc_hd__decap_3
XPHY_EDGE_ROW_48_Left_165 VGND VGND VPWR VPWR sky130_fd_sc_hd__decap_3
XFILLER_83_60 VGND VGND VPWR VPWR sky130_fd_sc_hd__decap_3
XFILLER_91_377 VGND VGND VPWR VPWR sky130_fd_sc_hd__fill_2
XFILLER_91_388 VGND VGND VPWR VPWR sky130_fd_sc_hd__decap_3
XTAP_TAPCELL_ROW_67_1061 VGND VPWR sky130_fd_sc_hd__tapvpwrvgnd_1
XTAP_TAPCELL_ROW_67_1050 VGND VPWR sky130_fd_sc_hd__tapvpwrvgnd_1
XFILLER_17_496 VGND VGND VPWR VPWR sky130_fd_sc_hd__fill_2
XFILLER_32_444 VGND VGND VPWR VPWR sky130_fd_sc_hd__decap_3
X_3840_ _6835_/Q _3886_/B1 _3917_/B1 _6840_/Q VGND VGND VPWR VPWR _3840_/X sky130_fd_sc_hd__a22o_2
X_3771_ _6910_/Q _3884_/A2 _3882_/A2 _6862_/Q VGND VGND VPWR VPWR _3771_/X sky130_fd_sc_hd__a22o_2
XTAP_TAPCELL_ROW_30_612 VGND VPWR sky130_fd_sc_hd__tapvpwrvgnd_1
XFILLER_9_651 VGND VGND VPWR VPWR sky130_fd_sc_hd__decap_3
XFILLER_73_3 VGND VGND VPWR VPWR sky130_fd_sc_hd__decap_3
X_6490_ _6548_/A VGND VGND VPWR VPWR _6490_/Y sky130_fd_sc_hd__inv_2
XFILLER_9_673 VGND VGND VPWR VPWR sky130_fd_sc_hd__decap_3
XPHY_EDGE_ROW_57_Left_174 VGND VGND VPWR VPWR sky130_fd_sc_hd__decap_3
XTAP_TAPCELL_ROW_78_1190 VGND VPWR sky130_fd_sc_hd__tapvpwrvgnd_1
X_7111_ _7337_/CLK _7111_/D _6391_/Y VGND VGND VPWR VPWR _7111_/Q sky130_fd_sc_hd__dfrtp_2
Xoutput469 _5657_/D VGND VGND VPWR VPWR alu_result_out[15] sky130_fd_sc_hd__clkdlybuf4s25_1
X_4323_ _7226_/Q _4469_/A3 _3968_/S _7194_/Q VGND VGND VPWR VPWR _4323_/X sky130_fd_sc_hd__a22o_2
XFILLER_99_433 VGND VGND VPWR VPWR sky130_fd_sc_hd__decap_3
XFILLER_113_243 VGND VGND VPWR VPWR sky130_fd_sc_hd__decap_3
XFILLER_87_606 VGND VGND VPWR VPWR sky130_fd_sc_hd__decap_3
XFILLER_87_617 VGND VGND VPWR VPWR sky130_fd_sc_hd__decap_3
X_7042_ _7390_/CLK _7042_/D _6322_/Y VGND VGND VPWR VPWR _7042_/Q sky130_fd_sc_hd__dfrtp_2
XFILLER_99_455 VGND VGND VPWR VPWR sky130_fd_sc_hd__decap_3
XFILLER_101_438 VGND VGND VPWR VPWR sky130_fd_sc_hd__decap_3
XFILLER_113_276 VGND VGND VPWR VPWR sky130_fd_sc_hd__decap_3
X_4254_ _7229_/Q _4469_/A3 _4517_/S _7042_/Q _4253_/X VGND VGND VPWR VPWR _4254_/X
+ sky130_fd_sc_hd__a221o_2
XFILLER_101_449 VGND VGND VPWR VPWR sky130_fd_sc_hd__decap_3
XFILLER_95_650 VGND VGND VPWR VPWR sky130_fd_sc_hd__decap_3
X_4185_ _4537_/C _4289_/B _4185_/C VGND VGND VPWR VPWR _4636_/B sky130_fd_sc_hd__and3_2
XFILLER_103_15 VGND VGND VPWR VPWR sky130_fd_sc_hd__decap_3
XFILLER_55_503 VGND VGND VPWR VPWR sky130_fd_sc_hd__fill_1
XFILLER_94_160 VGND VGND VPWR VPWR sky130_fd_sc_hd__decap_3
XTAP_TAPCELL_ROW_38_712 VGND VPWR sky130_fd_sc_hd__tapvpwrvgnd_1
XPHY_EDGE_ROW_66_Left_183 VGND VGND VPWR VPWR sky130_fd_sc_hd__decap_3
XFILLER_27_249 VGND VGND VPWR VPWR sky130_fd_sc_hd__decap_3
XFILLER_94_182 VGND VGND VPWR VPWR sky130_fd_sc_hd__decap_3
XFILLER_42_219 VGND VGND VPWR VPWR sky130_fd_sc_hd__decap_3
XFILLER_63_19 VGND VGND VPWR VPWR sky130_fd_sc_hd__decap_3
XFILLER_70_539 VGND VGND VPWR VPWR sky130_fd_sc_hd__decap_3
XFILLER_82_399 VGND VGND VPWR VPWR sky130_fd_sc_hd__decap_3
X_6826_ _6909_/CLK _6826_/D VGND VGND VPWR VPWR _6826_/Q sky130_fd_sc_hd__dfxtp_2
XFILLER_50_274 VGND VGND VPWR VPWR sky130_fd_sc_hd__decap_3
X_6757_ _6971_/CLK _6757_/D VGND VGND VPWR VPWR _6757_/Q sky130_fd_sc_hd__dfxtp_2
XFILLER_109_505 VGND VGND VPWR VPWR sky130_fd_sc_hd__fill_1
XFILLER_10_127 VGND VGND VPWR VPWR sky130_fd_sc_hd__decap_3
XFILLER_12_12 VGND VGND VPWR VPWR sky130_fd_sc_hd__decap_3
X_5708_ _7360_/Q hold922/X _5708_/S VGND VGND VPWR VPWR _6704_/D sky130_fd_sc_hd__mux2_2
XFILLER_6_109 VGND VGND VPWR VPWR sky130_fd_sc_hd__decap_3
X_6688_ _7383_/CLK _6688_/D VGND VGND VPWR VPWR _6688_/Q sky130_fd_sc_hd__dfxtp_2
XPHY_EDGE_ROW_75_Left_192 VGND VGND VPWR VPWR sky130_fd_sc_hd__decap_3
XFILLER_12_56 VGND VGND VPWR VPWR sky130_fd_sc_hd__decap_3
XFILLER_88_27 VGND VGND VPWR VPWR sky130_fd_sc_hd__fill_1
XFILLER_5_6 VGND VGND VPWR VPWR sky130_fd_sc_hd__decap_3
X_7309_ _7310_/CLK _7309_/D _6589_/Y VGND VGND VPWR VPWR _7309_/Q sky130_fd_sc_hd__dfrtp_2
XFILLER_104_265 VGND VGND VPWR VPWR sky130_fd_sc_hd__fill_2
XFILLER_78_628 VGND VGND VPWR VPWR sky130_fd_sc_hd__decap_3
XFILLER_104_276 VGND VGND VPWR VPWR sky130_fd_sc_hd__decap_3
XFILLER_77_116 VGND VGND VPWR VPWR sky130_fd_sc_hd__decap_3
XFILLER_77_138 VGND VGND VPWR VPWR sky130_fd_sc_hd__decap_3
XFILLER_58_330 VGND VGND VPWR VPWR sky130_fd_sc_hd__decap_3
XFILLER_37_42 VGND VGND VPWR VPWR sky130_fd_sc_hd__decap_3
XFILLER_58_374 VGND VGND VPWR VPWR sky130_fd_sc_hd__decap_3
XFILLER_86_672 VGND VGND VPWR VPWR sky130_fd_sc_hd__decap_3
XFILLER_46_558 VGND VGND VPWR VPWR sky130_fd_sc_hd__decap_3
XFILLER_54_580 VGND VGND VPWR VPWR sky130_fd_sc_hd__decap_3
XFILLER_61_539 VGND VGND VPWR VPWR sky130_fd_sc_hd__decap_3
XFILLER_73_388 VGND VGND VPWR VPWR sky130_fd_sc_hd__decap_3
XTAP_TAPCELL_ROW_16_439 VGND VPWR sky130_fd_sc_hd__tapvpwrvgnd_1
XFILLER_26_293 VGND VGND VPWR VPWR sky130_fd_sc_hd__decap_3
XFILLER_53_30 VGND VGND VPWR VPWR sky130_fd_sc_hd__fill_1
XFILLER_14_477 VGND VGND VPWR VPWR sky130_fd_sc_hd__fill_1
XFILLER_41_252 VGND VGND VPWR VPWR sky130_fd_sc_hd__decap_3
XFILLER_41_296 VGND VGND VPWR VPWR sky130_fd_sc_hd__fill_1
XFILLER_10_683 VGND VGND VPWR VPWR sky130_fd_sc_hd__decap_3
XFILLER_5_131 VGND VGND VPWR VPWR sky130_fd_sc_hd__decap_3
XFILLER_115_508 VGND VGND VPWR VPWR sky130_fd_sc_hd__decap_3
XFILLER_5_164 VGND VGND VPWR VPWR sky130_fd_sc_hd__decap_3
XFILLER_6_676 VGND VGND VPWR VPWR sky130_fd_sc_hd__decap_3
XTAP_TAPCELL_ROW_114_1622 VGND VPWR sky130_fd_sc_hd__tapvpwrvgnd_1
XFILLER_69_606 VGND VGND VPWR VPWR sky130_fd_sc_hd__decap_3
XFILLER_69_617 VGND VGND VPWR VPWR sky130_fd_sc_hd__decap_3
XFILLER_78_60 VGND VGND VPWR VPWR sky130_fd_sc_hd__decap_3
XFILLER_1_370 VGND VGND VPWR VPWR sky130_fd_sc_hd__decap_3
XFILLER_38_6 VGND VGND VPWR VPWR sky130_fd_sc_hd__decap_3
XFILLER_68_127 VGND VGND VPWR VPWR sky130_fd_sc_hd__decap_3
XFILLER_68_149 VGND VGND VPWR VPWR sky130_fd_sc_hd__decap_3
XFILLER_37_503 VGND VGND VPWR VPWR sky130_fd_sc_hd__fill_1
XFILLER_37_514 VGND VGND VPWR VPWR sky130_fd_sc_hd__decap_3
XFILLER_64_300 VGND VGND VPWR VPWR sky130_fd_sc_hd__decap_3
XFILLER_83_119 VGND VGND VPWR VPWR sky130_fd_sc_hd__decap_3
XFILLER_49_396 VGND VGND VPWR VPWR sky130_fd_sc_hd__fill_2
XFILLER_76_171 VGND VGND VPWR VPWR sky130_fd_sc_hd__decap_3
XFILLER_92_620 VGND VGND VPWR VPWR sky130_fd_sc_hd__decap_3
XFILLER_92_675 VGND VGND VPWR VPWR sky130_fd_sc_hd__decap_3
XFILLER_64_388 VGND VGND VPWR VPWR sky130_fd_sc_hd__decap_3
X_4941_ _4811_/C _4936_/Y _4940_/Y VGND VGND VPWR VPWR _5657_/C sky130_fd_sc_hd__a21o_2
X_4872_ _4872_/A _4872_/B VGND VGND VPWR VPWR _4872_/X sky130_fd_sc_hd__and2_2
XFILLER_32_274 VGND VGND VPWR VPWR sky130_fd_sc_hd__decap_3
X_6611_ _6611_/A VGND VGND VPWR VPWR _6611_/Y sky130_fd_sc_hd__inv_2
X_3823_ _6947_/Q _3913_/B1 _3912_/B1 _6959_/Q VGND VGND VPWR VPWR _3823_/X sky130_fd_sc_hd__a22o_2
XTAP_TAPCELL_ROW_43_770 VGND VPWR sky130_fd_sc_hd__tapvpwrvgnd_1
XFILLER_20_436 VGND VGND VPWR VPWR sky130_fd_sc_hd__decap_3
X_6542_ _6548_/A VGND VGND VPWR VPWR _6542_/Y sky130_fd_sc_hd__inv_2
X_3754_ _3754_/A1 _3757_/S _3753_/X VGND VGND VPWR VPWR _7397_/D sky130_fd_sc_hd__o21a_2
X_6473_ _6576_/A VGND VGND VPWR VPWR _6473_/Y sky130_fd_sc_hd__inv_2
XFILLER_114_563 VGND VGND VPWR VPWR sky130_fd_sc_hd__decap_3
XFILLER_59_105 VGND VGND VPWR VPWR sky130_fd_sc_hd__decap_3
XFILLER_59_116 VGND VGND VPWR VPWR sky130_fd_sc_hd__fill_1
XFILLER_59_127 VGND VGND VPWR VPWR sky130_fd_sc_hd__decap_3
X_5286_ _5286_/A0 _5139_/X _5292_/S VGND VGND VPWR VPWR _7186_/D sky130_fd_sc_hd__mux2_2
X_4306_ _7288_/Q _3415_/X _3417_/X _7096_/Q VGND VGND VPWR VPWR _4311_/A sky130_fd_sc_hd__a22o_2
XFILLER_99_296 VGND VGND VPWR VPWR sky130_fd_sc_hd__fill_2
XFILLER_59_149 VGND VGND VPWR VPWR sky130_fd_sc_hd__decap_3
XFILLER_87_458 VGND VGND VPWR VPWR sky130_fd_sc_hd__decap_3
X_7025_ _7372_/CLK _7025_/D _6305_/Y VGND VGND VPWR VPWR _7025_/Q sky130_fd_sc_hd__dfrtp_2
X_4237_ _7259_/Q _4341_/A2 _4236_/X VGND VGND VPWR VPWR _4237_/X sky130_fd_sc_hd__a21o_2
XFILLER_101_279 VGND VGND VPWR VPWR sky130_fd_sc_hd__fill_1
XFILLER_114_47 VGND VGND VPWR VPWR sky130_fd_sc_hd__decap_3
XFILLER_68_672 VGND VGND VPWR VPWR sky130_fd_sc_hd__decap_3
XFILLER_28_536 VGND VGND VPWR VPWR sky130_fd_sc_hd__decap_3
XFILLER_55_333 VGND VGND VPWR VPWR sky130_fd_sc_hd__decap_3
XFILLER_74_29 VGND VGND VPWR VPWR sky130_fd_sc_hd__decap_3
XFILLER_83_620 VGND VGND VPWR VPWR sky130_fd_sc_hd__decap_3
X_4168_ _7046_/Q _4501_/S _4394_/B _7361_/Q _4167_/X VGND VGND VPWR VPWR _4168_/X
+ sky130_fd_sc_hd__a221o_2
XFILLER_55_366 VGND VGND VPWR VPWR sky130_fd_sc_hd__decap_3
XFILLER_82_141 VGND VGND VPWR VPWR sky130_fd_sc_hd__decap_3
XFILLER_83_653 VGND VGND VPWR VPWR sky130_fd_sc_hd__decap_3
X_4099_ _7301_/Q _4493_/S _4430_/B1 _7173_/Q _4098_/X VGND VGND VPWR VPWR _4099_/X
+ sky130_fd_sc_hd__a221o_2
XFILLER_15_219 VGND VGND VPWR VPWR sky130_fd_sc_hd__decap_3
XFILLER_51_550 VGND VGND VPWR VPWR sky130_fd_sc_hd__decap_3
XFILLER_90_17 VGND VGND VPWR VPWR sky130_fd_sc_hd__decap_3
XFILLER_23_252 VGND VGND VPWR VPWR sky130_fd_sc_hd__decap_3
XFILLER_51_561 VGND VGND VPWR VPWR sky130_fd_sc_hd__fill_1
X_6809_ _6976_/CLK _6809_/D VGND VGND VPWR VPWR _6809_/Q sky130_fd_sc_hd__dfxtp_2
XTAP_TAPCELL_ROW_13_409 VGND VPWR sky130_fd_sc_hd__tapvpwrvgnd_1
XPHY_EDGE_ROW_83_Left_200 VGND VGND VPWR VPWR sky130_fd_sc_hd__decap_3
XFILLER_23_33 VGND VGND VPWR VPWR sky130_fd_sc_hd__decap_3
XFILLER_23_66 VGND VGND VPWR VPWR sky130_fd_sc_hd__decap_3
XFILLER_23_99 VGND VGND VPWR VPWR sky130_fd_sc_hd__decap_3
XFILLER_2_112 VGND VGND VPWR VPWR sky130_fd_sc_hd__decap_3
XFILLER_3_646 VGND VGND VPWR VPWR sky130_fd_sc_hd__decap_3
XFILLER_2_156 VGND VGND VPWR VPWR sky130_fd_sc_hd__decap_3
XFILLER_3_3 VGND VGND VPWR VPWR sky130_fd_sc_hd__decap_3
XFILLER_3_679 VGND VGND VPWR VPWR sky130_fd_sc_hd__decap_3
XFILLER_59_650 VGND VGND VPWR VPWR sky130_fd_sc_hd__decap_3
XFILLER_19_503 VGND VGND VPWR VPWR sky130_fd_sc_hd__fill_1
XFILLER_46_300 VGND VGND VPWR VPWR sky130_fd_sc_hd__decap_3
XFILLER_48_63 VGND VGND VPWR VPWR sky130_fd_sc_hd__decap_3
XFILLER_65_108 VGND VGND VPWR VPWR sky130_fd_sc_hd__decap_3
XFILLER_65_119 VGND VGND VPWR VPWR sky130_fd_sc_hd__decap_3
XFILLER_93_406 VGND VGND VPWR VPWR sky130_fd_sc_hd__fill_2
XFILLER_58_171 VGND VGND VPWR VPWR sky130_fd_sc_hd__fill_1
XFILLER_104_80 VGND VGND VPWR VPWR sky130_fd_sc_hd__decap_3
XFILLER_74_675 VGND VGND VPWR VPWR sky130_fd_sc_hd__decap_3
XFILLER_104_91 VGND VGND VPWR VPWR sky130_fd_sc_hd__decap_3
XFILLER_46_388 VGND VGND VPWR VPWR sky130_fd_sc_hd__decap_3
XFILLER_61_325 VGND VGND VPWR VPWR sky130_fd_sc_hd__decap_3
XFILLER_64_40 VGND VGND VPWR VPWR sky130_fd_sc_hd__decap_3
XFILLER_64_73 VGND VGND VPWR VPWR sky130_fd_sc_hd__fill_2
XFILLER_73_185 VGND VGND VPWR VPWR sky130_fd_sc_hd__decap_3
XTAP_TAPCELL_ROW_29_597 VGND VPWR sky130_fd_sc_hd__tapvpwrvgnd_1
XFILLER_14_230 VGND VGND VPWR VPWR sky130_fd_sc_hd__decap_3
XFILLER_61_358 VGND VGND VPWR VPWR sky130_fd_sc_hd__decap_3
XTAP_TAPCELL_ROW_64_1020 VGND VPWR sky130_fd_sc_hd__tapvpwrvgnd_1
XFILLER_9_24 VGND VGND VPWR VPWR sky130_fd_sc_hd__decap_3
XFILLER_9_57 VGND VGND VPWR VPWR sky130_fd_sc_hd__decap_3
XFILLER_80_83 VGND VGND VPWR VPWR sky130_fd_sc_hd__fill_1
XFILLER_6_451 VGND VGND VPWR VPWR sky130_fd_sc_hd__decap_3
Xhold908 _6693_/Q VGND VGND VPWR VPWR hold908/X sky130_fd_sc_hd__dlygate4sd3_1
Xhold919 _6700_/Q VGND VGND VPWR VPWR hold919/X sky130_fd_sc_hd__dlygate4sd3_1
XFILLER_115_349 VGND VGND VPWR VPWR sky130_fd_sc_hd__decap_3
X_3470_ _3468_/X _3424_/S _4537_/C _4537_/B VGND VGND VPWR VPWR _3545_/B sky130_fd_sc_hd__o2bb2a_2
XFILLER_89_92 VGND VGND VPWR VPWR sky130_fd_sc_hd__decap_3
XFILLER_36_3 VGND VGND VPWR VPWR sky130_fd_sc_hd__decap_3
XFILLER_69_436 VGND VGND VPWR VPWR sky130_fd_sc_hd__decap_3
X_5140_ _5140_/A0 _5139_/X _5157_/S VGND VGND VPWR VPWR _7250_/D sky130_fd_sc_hd__mux2_2
XFILLER_2_690 VGND VGND VPWR VPWR sky130_fd_sc_hd__fill_2
XFILLER_57_609 VGND VGND VPWR VPWR sky130_fd_sc_hd__decap_3
X_5071_ _5071_/A _5071_/B VGND VGND VPWR VPWR _5072_/C sky130_fd_sc_hd__nand2_2
XFILLER_111_588 VGND VGND VPWR VPWR sky130_fd_sc_hd__decap_3
XFILLER_84_406 VGND VGND VPWR VPWR sky130_fd_sc_hd__decap_3
XFILLER_65_620 VGND VGND VPWR VPWR sky130_fd_sc_hd__decap_3
XFILLER_64_130 VGND VGND VPWR VPWR sky130_fd_sc_hd__decap_3
XFILLER_64_141 VGND VGND VPWR VPWR sky130_fd_sc_hd__decap_3
XFILLER_65_653 VGND VGND VPWR VPWR sky130_fd_sc_hd__decap_3
XFILLER_64_174 VGND VGND VPWR VPWR sky130_fd_sc_hd__fill_1
XFILLER_64_185 VGND VGND VPWR VPWR sky130_fd_sc_hd__decap_3
XFILLER_80_612 VGND VGND VPWR VPWR sky130_fd_sc_hd__decap_3
XFILLER_92_483 VGND VGND VPWR VPWR sky130_fd_sc_hd__decap_3
XFILLER_52_336 VGND VGND VPWR VPWR sky130_fd_sc_hd__decap_3
XFILLER_80_645 VGND VGND VPWR VPWR sky130_fd_sc_hd__decap_3
XFILLER_80_678 VGND VGND VPWR VPWR sky130_fd_sc_hd__decap_3
X_4924_ _4920_/A _4922_/X _4923_/Y VGND VGND VPWR VPWR _4924_/X sky130_fd_sc_hd__a21o_2
XFILLER_100_16 VGND VGND VPWR VPWR sky130_fd_sc_hd__decap_3
XFILLER_100_49 VGND VGND VPWR VPWR sky130_fd_sc_hd__decap_3
XFILLER_20_200 VGND VGND VPWR VPWR sky130_fd_sc_hd__fill_2
XFILLER_20_211 VGND VGND VPWR VPWR sky130_fd_sc_hd__decap_3
XFILLER_60_391 VGND VGND VPWR VPWR sky130_fd_sc_hd__decap_3
X_4855_ _4855_/A _4855_/B _4854_/X VGND VGND VPWR VPWR _5655_/D sky130_fd_sc_hd__or3b_4
X_4786_ _4795_/A _4795_/B _4648_/A VGND VGND VPWR VPWR _4787_/B sky130_fd_sc_hd__a21o_2
X_3806_ _6966_/Q _3884_/A2 _3883_/A2 _6954_/Q _3805_/X VGND VGND VPWR VPWR _3806_/X
+ sky130_fd_sc_hd__a221o_2
X_6525_ _6525_/A VGND VGND VPWR VPWR _6525_/Y sky130_fd_sc_hd__inv_2
X_3737_ _6752_/Q _3884_/A2 _3883_/B1 _6746_/Q VGND VGND VPWR VPWR _3737_/X sky130_fd_sc_hd__a22o_2
XFILLER_109_36 VGND VGND VPWR VPWR sky130_fd_sc_hd__decap_3
XFILLER_109_69 VGND VGND VPWR VPWR sky130_fd_sc_hd__decap_3
XFILLER_69_18 VGND VGND VPWR VPWR sky130_fd_sc_hd__decap_3
X_6456_ _6616_/A VGND VGND VPWR VPWR _6456_/Y sky130_fd_sc_hd__inv_2
X_3668_ _6943_/Q _3768_/A2 _3767_/B1 _6895_/Q VGND VGND VPWR VPWR _3668_/X sky130_fd_sc_hd__a22o_2
X_6387_ _6578_/A VGND VGND VPWR VPWR _6387_/Y sky130_fd_sc_hd__inv_2
X_5407_ _5407_/A0 _5061_/X _5429_/S VGND VGND VPWR VPWR _7130_/D sky130_fd_sc_hd__mux2_2
X_3599_ _3599_/A _3600_/A VGND VGND VPWR VPWR _4614_/C sky130_fd_sc_hd__nor2_2
XFILLER_0_638 VGND VGND VPWR VPWR sky130_fd_sc_hd__decap_3
XFILLER_114_360 VGND VGND VPWR VPWR sky130_fd_sc_hd__decap_3
XFILLER_87_200 VGND VGND VPWR VPWR sky130_fd_sc_hd__decap_3
X_5338_ _5338_/A0 _5061_/X _5360_/S VGND VGND VPWR VPWR _7162_/D sky130_fd_sc_hd__mux2_2
XFILLER_102_533 VGND VGND VPWR VPWR sky130_fd_sc_hd__decap_3
XFILLER_102_555 VGND VGND VPWR VPWR sky130_fd_sc_hd__decap_3
XFILLER_85_17 VGND VGND VPWR VPWR sky130_fd_sc_hd__decap_3
XFILLER_87_222 VGND VGND VPWR VPWR sky130_fd_sc_hd__fill_2
XFILLER_75_417 VGND VGND VPWR VPWR sky130_fd_sc_hd__decap_3
XFILLER_87_266 VGND VGND VPWR VPWR sky130_fd_sc_hd__decap_3
X_7008_ _7374_/CLK _7008_/D _6288_/Y VGND VGND VPWR VPWR _7008_/Q sky130_fd_sc_hd__dfrtp_2
XTAP_TAPCELL_ROW_89_1318 VGND VPWR sky130_fd_sc_hd__tapvpwrvgnd_1
XFILLER_56_631 VGND VGND VPWR VPWR sky130_fd_sc_hd__decap_3
XFILLER_55_130 VGND VGND VPWR VPWR sky130_fd_sc_hd__decap_3
XFILLER_18_88 VGND VGND VPWR VPWR sky130_fd_sc_hd__fill_1
XFILLER_56_686 VGND VGND VPWR VPWR sky130_fd_sc_hd__decap_3
XFILLER_83_483 VGND VGND VPWR VPWR sky130_fd_sc_hd__decap_3
XFILLER_34_21 VGND VGND VPWR VPWR sky130_fd_sc_hd__decap_3
XFILLER_70_133 VGND VGND VPWR VPWR sky130_fd_sc_hd__fill_2
XFILLER_70_144 VGND VGND VPWR VPWR sky130_fd_sc_hd__decap_3
XFILLER_71_656 VGND VGND VPWR VPWR sky130_fd_sc_hd__decap_3
XFILLER_70_177 VGND VGND VPWR VPWR sky130_fd_sc_hd__decap_3
XTAP_TAPCELL_ROW_54_898 VGND VPWR sky130_fd_sc_hd__tapvpwrvgnd_1
XTAP_TAPCELL_ROW_26_567 VGND VPWR sky130_fd_sc_hd__tapvpwrvgnd_1
XFILLER_34_76 VGND VGND VPWR VPWR sky130_fd_sc_hd__decap_3
XFILLER_109_143 VGND VGND VPWR VPWR sky130_fd_sc_hd__decap_3
XFILLER_50_64 VGND VGND VPWR VPWR sky130_fd_sc_hd__decap_3
XFILLER_7_259 VGND VGND VPWR VPWR sky130_fd_sc_hd__decap_3
XFILLER_109_187 VGND VGND VPWR VPWR sky130_fd_sc_hd__decap_3
XFILLER_3_432 VGND VGND VPWR VPWR sky130_fd_sc_hd__decap_3
XFILLER_105_371 VGND VGND VPWR VPWR sky130_fd_sc_hd__decap_3
XFILLER_59_51 VGND VGND VPWR VPWR sky130_fd_sc_hd__decap_3
XFILLER_78_200 VGND VGND VPWR VPWR sky130_fd_sc_hd__decap_3
XFILLER_105_393 VGND VGND VPWR VPWR sky130_fd_sc_hd__decap_3
XFILLER_78_222 VGND VGND VPWR VPWR sky130_fd_sc_hd__decap_3
XFILLER_22_9 VGND VGND VPWR VPWR sky130_fd_sc_hd__decap_3
XFILLER_38_108 VGND VGND VPWR VPWR sky130_fd_sc_hd__decap_3
XFILLER_66_406 VGND VGND VPWR VPWR sky130_fd_sc_hd__decap_3
XFILLER_66_428 VGND VGND VPWR VPWR sky130_fd_sc_hd__decap_3
XFILLER_115_90 VGND VGND VPWR VPWR sky130_fd_sc_hd__decap_3
XFILLER_47_620 VGND VGND VPWR VPWR sky130_fd_sc_hd__decap_3
XFILLER_59_491 VGND VGND VPWR VPWR sky130_fd_sc_hd__decap_3
XTAP_TAPCELL_ROW_70_1090 VGND VPWR sky130_fd_sc_hd__tapvpwrvgnd_1
XFILLER_19_366 VGND VGND VPWR VPWR sky130_fd_sc_hd__decap_3
XFILLER_46_141 VGND VGND VPWR VPWR sky130_fd_sc_hd__decap_3
XFILLER_47_653 VGND VGND VPWR VPWR sky130_fd_sc_hd__decap_3
XFILLER_75_72 VGND VGND VPWR VPWR sky130_fd_sc_hd__decap_3
XTAP_TAPCELL_ROW_109_1554 VGND VPWR sky130_fd_sc_hd__tapvpwrvgnd_1
XFILLER_19_377 VGND VGND VPWR VPWR sky130_fd_sc_hd__decap_3
XFILLER_61_100 VGND VGND VPWR VPWR sky130_fd_sc_hd__decap_3
XFILLER_62_601 VGND VGND VPWR VPWR sky130_fd_sc_hd__decap_3
XFILLER_62_634 VGND VGND VPWR VPWR sky130_fd_sc_hd__decap_3
XTAP_TAPCELL_ROW_109_1565 VGND VPWR sky130_fd_sc_hd__tapvpwrvgnd_1
XFILLER_62_645 VGND VGND VPWR VPWR sky130_fd_sc_hd__decap_3
XFILLER_61_166 VGND VGND VPWR VPWR sky130_fd_sc_hd__fill_2
XFILLER_61_177 VGND VGND VPWR VPWR sky130_fd_sc_hd__fill_1
XFILLER_62_678 VGND VGND VPWR VPWR sky130_fd_sc_hd__decap_3
XFILLER_91_60 VGND VGND VPWR VPWR sky130_fd_sc_hd__decap_3
XFILLER_15_583 VGND VGND VPWR VPWR sky130_fd_sc_hd__decap_3
XFILLER_42_391 VGND VGND VPWR VPWR sky130_fd_sc_hd__fill_2
X_4640_ _4938_/B _4918_/A VGND VGND VPWR VPWR _4640_/Y sky130_fd_sc_hd__nor2_2
X_6310_ _6634_/A VGND VGND VPWR VPWR _6310_/Y sky130_fd_sc_hd__inv_2
X_4571_ _4571_/A _4571_/B VGND VGND VPWR VPWR _7295_/D sky130_fd_sc_hd__and2_2
XFILLER_115_102 VGND VGND VPWR VPWR sky130_fd_sc_hd__decap_3
XFILLER_115_113 VGND VGND VPWR VPWR sky130_fd_sc_hd__decap_3
X_7290_ _7352_/CLK _7290_/D _6570_/Y VGND VGND VPWR VPWR _7290_/Q sky130_fd_sc_hd__dfrtp_2
Xhold705 _6729_/Q VGND VGND VPWR VPWR _6729_/D sky130_fd_sc_hd__dlygate4sd3_1
Xhold716 _6911_/Q VGND VGND VPWR VPWR _6911_/D sky130_fd_sc_hd__dlygate4sd3_1
Xhold727 _6852_/Q VGND VGND VPWR VPWR _6852_/D sky130_fd_sc_hd__dlygate4sd3_1
X_3522_ _5118_/C _4938_/A _3618_/C VGND VGND VPWR VPWR _3522_/Y sky130_fd_sc_hd__nand3_2
XFILLER_115_146 VGND VGND VPWR VPWR sky130_fd_sc_hd__decap_3
Xhold738 _6753_/Q VGND VGND VPWR VPWR _6753_/D sky130_fd_sc_hd__dlygate4sd3_1
Xhold749 _6749_/Q VGND VGND VPWR VPWR _6749_/D sky130_fd_sc_hd__dlygate4sd3_1
X_3453_ _7218_/Q _4331_/A2 _4332_/B1 _7378_/Q VGND VGND VPWR VPWR _3453_/X sky130_fd_sc_hd__a22o_2
XFILLER_103_308 VGND VGND VPWR VPWR sky130_fd_sc_hd__fill_2
XFILLER_103_319 VGND VGND VPWR VPWR sky130_fd_sc_hd__decap_3
XFILLER_69_211 VGND VGND VPWR VPWR sky130_fd_sc_hd__decap_3
XFILLER_97_531 VGND VGND VPWR VPWR sky130_fd_sc_hd__fill_2
X_3384_ _7315_/Q _3987_/S _4528_/B _7283_/Q VGND VGND VPWR VPWR _3384_/X sky130_fd_sc_hd__a22o_2
XFILLER_69_255 VGND VGND VPWR VPWR sky130_fd_sc_hd__fill_1
XFILLER_69_266 VGND VGND VPWR VPWR sky130_fd_sc_hd__decap_3
XFILLER_97_564 VGND VGND VPWR VPWR sky130_fd_sc_hd__decap_3
XFILLER_111_396 VGND VGND VPWR VPWR sky130_fd_sc_hd__fill_1
XFILLER_38_620 VGND VGND VPWR VPWR sky130_fd_sc_hd__decap_3
XFILLER_69_299 VGND VGND VPWR VPWR sky130_fd_sc_hd__decap_3
X_5054_ _5054_/A VGND VGND VPWR VPWR _5054_/Y sky130_fd_sc_hd__inv_2
XFILLER_84_247 VGND VGND VPWR VPWR sky130_fd_sc_hd__decap_3
XFILLER_25_325 VGND VGND VPWR VPWR sky130_fd_sc_hd__decap_3
XFILLER_37_163 VGND VGND VPWR VPWR sky130_fd_sc_hd__decap_3
XFILLER_38_675 VGND VGND VPWR VPWR sky130_fd_sc_hd__decap_3
XFILLER_53_601 VGND VGND VPWR VPWR sky130_fd_sc_hd__decap_3
XFILLER_53_623 VGND VGND VPWR VPWR sky130_fd_sc_hd__decap_3
XFILLER_65_483 VGND VGND VPWR VPWR sky130_fd_sc_hd__decap_3
XFILLER_111_15 VGND VGND VPWR VPWR sky130_fd_sc_hd__fill_2
XFILLER_111_26 VGND VGND VPWR VPWR sky130_fd_sc_hd__decap_3
XFILLER_53_656 VGND VGND VPWR VPWR sky130_fd_sc_hd__decap_3
XTAP_TAPCELL_ROW_84_1259 VGND VPWR sky130_fd_sc_hd__tapvpwrvgnd_1
XFILLER_40_306 VGND VGND VPWR VPWR sky130_fd_sc_hd__fill_2
XFILLER_52_144 VGND VGND VPWR VPWR sky130_fd_sc_hd__decap_3
XFILLER_80_475 VGND VGND VPWR VPWR sky130_fd_sc_hd__fill_1
XFILLER_80_486 VGND VGND VPWR VPWR sky130_fd_sc_hd__decap_3
X_4907_ _4948_/A _4888_/B _4903_/X _4906_/X VGND VGND VPWR VPWR _5657_/B sky130_fd_sc_hd__o31ai_4
XTAP_TAPCELL_ROW_23_526 VGND VPWR sky130_fd_sc_hd__tapvpwrvgnd_1
XTAP_TAPCELL_ROW_51_868 VGND VPWR sky130_fd_sc_hd__tapvpwrvgnd_1
X_4769_ _4969_/B _4741_/X _4761_/Y _4768_/Y VGND VGND VPWR VPWR _5663_/A sky130_fd_sc_hd__a31o_2
XFILLER_107_647 VGND VGND VPWR VPWR sky130_fd_sc_hd__decap_3
XFILLER_20_12 VGND VGND VPWR VPWR sky130_fd_sc_hd__decap_3
XFILLER_20_34 VGND VGND VPWR VPWR sky130_fd_sc_hd__decap_3
X_6508_ _6608_/A VGND VGND VPWR VPWR _6508_/Y sky130_fd_sc_hd__inv_2
XFILLER_105_6 VGND VGND VPWR VPWR sky130_fd_sc_hd__decap_3
XFILLER_20_67 VGND VGND VPWR VPWR sky130_fd_sc_hd__decap_3
X_6439_ _6532_/A VGND VGND VPWR VPWR _6439_/Y sky130_fd_sc_hd__inv_2
XTAP_TAPCELL_ROW_95_1388 VGND VPWR sky130_fd_sc_hd__tapvpwrvgnd_1
XFILLER_0_402 VGND VGND VPWR VPWR sky130_fd_sc_hd__decap_3
XFILLER_0_424 VGND VGND VPWR VPWR sky130_fd_sc_hd__decap_3
XFILLER_0_446 VGND VGND VPWR VPWR sky130_fd_sc_hd__fill_2
XFILLER_102_330 VGND VGND VPWR VPWR sky130_fd_sc_hd__decap_3
XFILLER_96_38 VGND VGND VPWR VPWR sky130_fd_sc_hd__decap_3
XFILLER_29_43 VGND VGND VPWR VPWR sky130_fd_sc_hd__decap_3
XFILLER_29_620 VGND VGND VPWR VPWR sky130_fd_sc_hd__decap_3
XFILLER_75_225 VGND VGND VPWR VPWR sky130_fd_sc_hd__fill_2
XFILLER_75_236 VGND VGND VPWR VPWR sky130_fd_sc_hd__decap_3
XFILLER_28_141 VGND VGND VPWR VPWR sky130_fd_sc_hd__decap_3
XFILLER_63_409 VGND VGND VPWR VPWR sky130_fd_sc_hd__decap_3
XTAP_TAPCELL_ROW_59_957 VGND VPWR sky130_fd_sc_hd__tapvpwrvgnd_1
XFILLER_56_461 VGND VGND VPWR VPWR sky130_fd_sc_hd__decap_3
XFILLER_56_483 VGND VGND VPWR VPWR sky130_fd_sc_hd__decap_3
Xplace409 _4429_/B1 VGND VGND VPWR VPWR _4437_/B1 sky130_fd_sc_hd__buf_2
XTAP_TAPCELL_ROW_3_284 VGND VPWR sky130_fd_sc_hd__tapvpwrvgnd_1
XPHY_EDGE_ROW_11_Left_128 VGND VGND VPWR VPWR sky130_fd_sc_hd__decap_3
XFILLER_16_358 VGND VGND VPWR VPWR sky130_fd_sc_hd__decap_3
XFILLER_28_185 VGND VGND VPWR VPWR sky130_fd_sc_hd__decap_3
XFILLER_43_122 VGND VGND VPWR VPWR sky130_fd_sc_hd__fill_2
XFILLER_45_53 VGND VGND VPWR VPWR sky130_fd_sc_hd__decap_3
XFILLER_83_291 VGND VGND VPWR VPWR sky130_fd_sc_hd__decap_3
XFILLER_45_86 VGND VGND VPWR VPWR sky130_fd_sc_hd__decap_3
XFILLER_71_464 VGND VGND VPWR VPWR sky130_fd_sc_hd__decap_3
XFILLER_31_328 VGND VGND VPWR VPWR sky130_fd_sc_hd__decap_3
XFILLER_101_92 VGND VGND VPWR VPWR sky130_fd_sc_hd__decap_3
XFILLER_12_564 VGND VGND VPWR VPWR sky130_fd_sc_hd__decap_3
XFILLER_24_391 VGND VGND VPWR VPWR sky130_fd_sc_hd__decap_3
XFILLER_61_30 VGND VGND VPWR VPWR sky130_fd_sc_hd__fill_2
XTAP_TAPCELL_ROW_104_1495 VGND VPWR sky130_fd_sc_hd__tapvpwrvgnd_1
XFILLER_61_85 VGND VGND VPWR VPWR sky130_fd_sc_hd__decap_3
XFILLER_8_579 VGND VGND VPWR VPWR sky130_fd_sc_hd__fill_1
XANTENNA_7 _7366_/Q VGND VGND VPWR VPWR sky130_fd_sc_hd__diode_2
XFILLER_6_47 VGND VGND VPWR VPWR sky130_fd_sc_hd__decap_3
XPHY_EDGE_ROW_20_Left_137 VGND VGND VPWR VPWR sky130_fd_sc_hd__decap_3
XFILLER_113_606 VGND VGND VPWR VPWR sky130_fd_sc_hd__decap_3
XFILLER_113_617 VGND VGND VPWR VPWR sky130_fd_sc_hd__decap_3
XFILLER_98_328 VGND VGND VPWR VPWR sky130_fd_sc_hd__decap_3
XFILLER_112_127 VGND VGND VPWR VPWR sky130_fd_sc_hd__decap_3
XFILLER_20_6 VGND VGND VPWR VPWR sky130_fd_sc_hd__decap_3
XFILLER_79_564 VGND VGND VPWR VPWR sky130_fd_sc_hd__decap_3
XFILLER_94_501 VGND VGND VPWR VPWR sky130_fd_sc_hd__decap_3
XFILLER_66_203 VGND VGND VPWR VPWR sky130_fd_sc_hd__fill_2
XFILLER_66_225 VGND VGND VPWR VPWR sky130_fd_sc_hd__decap_3
XFILLER_86_82 VGND VGND VPWR VPWR sky130_fd_sc_hd__fill_2
XFILLER_94_523 VGND VGND VPWR VPWR sky130_fd_sc_hd__decap_3
XFILLER_34_100 VGND VGND VPWR VPWR sky130_fd_sc_hd__decap_3
XFILLER_81_228 VGND VGND VPWR VPWR sky130_fd_sc_hd__decap_3
XFILLER_94_589 VGND VGND VPWR VPWR sky130_fd_sc_hd__decap_3
XFILLER_34_133 VGND VGND VPWR VPWR sky130_fd_sc_hd__decap_3
XFILLER_22_306 VGND VGND VPWR VPWR sky130_fd_sc_hd__fill_2
XFILLER_34_144 VGND VGND VPWR VPWR sky130_fd_sc_hd__decap_3
XFILLER_50_615 VGND VGND VPWR VPWR sky130_fd_sc_hd__decap_3
XFILLER_62_453 VGND VGND VPWR VPWR sky130_fd_sc_hd__decap_3
X_6790_ _6965_/CLK _6790_/D VGND VGND VPWR VPWR _6790_/Q sky130_fd_sc_hd__dfxtp_2
XFILLER_15_380 VGND VGND VPWR VPWR sky130_fd_sc_hd__decap_3
XFILLER_50_648 VGND VGND VPWR VPWR sky130_fd_sc_hd__decap_3
XFILLER_62_497 VGND VGND VPWR VPWR sky130_fd_sc_hd__decap_3
X_4623_ _4330_/B _4622_/X _5057_/B VGND VGND VPWR VPWR _4624_/A sky130_fd_sc_hd__o21ba_2
X_7342_ _7374_/CLK _7342_/D _6622_/Y VGND VGND VPWR VPWR _7342_/Q sky130_fd_sc_hd__dfrtp_2
X_4554_ _4554_/A _4563_/B VGND VGND VPWR VPWR _7303_/D sky130_fd_sc_hd__and2_2
X_7273_ _7337_/CLK _7273_/D _6553_/Y VGND VGND VPWR VPWR _7273_/Q sky130_fd_sc_hd__dfrtp_2
X_3505_ _3505_/A _3505_/B VGND VGND VPWR VPWR _3505_/X sky130_fd_sc_hd__or2_4
XFILLER_104_628 VGND VGND VPWR VPWR sky130_fd_sc_hd__decap_3
XFILLER_116_477 VGND VGND VPWR VPWR sky130_fd_sc_hd__decap_3
XFILLER_103_116 VGND VGND VPWR VPWR sky130_fd_sc_hd__decap_3
XFILLER_106_15 VGND VGND VPWR VPWR sky130_fd_sc_hd__decap_3
XFILLER_106_59 VGND VGND VPWR VPWR sky130_fd_sc_hd__decap_3
XFILLER_112_672 VGND VGND VPWR VPWR sky130_fd_sc_hd__decap_3
XFILLER_85_501 VGND VGND VPWR VPWR sky130_fd_sc_hd__decap_3
XFILLER_57_236 VGND VGND VPWR VPWR sky130_fd_sc_hd__decap_3
XFILLER_97_372 VGND VGND VPWR VPWR sky130_fd_sc_hd__decap_3
Xhold1202 _7158_/Q VGND VGND VPWR VPWR _5346_/A0 sky130_fd_sc_hd__dlygate4sd3_1
Xhold1213 _7322_/Q VGND VGND VPWR VPWR _4515_/A0 sky130_fd_sc_hd__dlygate4sd3_1
Xhold1224 _7391_/Q VGND VGND VPWR VPWR _3814_/A1 sky130_fd_sc_hd__dlygate4sd3_1
X_5106_ _6985_/Q _5068_/C _5581_/S VGND VGND VPWR VPWR _5106_/X sky130_fd_sc_hd__o21a_2
XFILLER_111_193 VGND VGND VPWR VPWR sky130_fd_sc_hd__decap_3
XFILLER_57_269 VGND VGND VPWR VPWR sky130_fd_sc_hd__decap_3
X_5037_ _6988_/Q _5045_/B VGND VGND VPWR VPWR _5038_/B sky130_fd_sc_hd__nand2_2
XFILLER_38_461 VGND VGND VPWR VPWR sky130_fd_sc_hd__decap_3
XFILLER_38_472 VGND VGND VPWR VPWR sky130_fd_sc_hd__decap_3
XTAP_TAPCELL_ROW_56_927 VGND VPWR sky130_fd_sc_hd__tapvpwrvgnd_1
XFILLER_25_122 VGND VGND VPWR VPWR sky130_fd_sc_hd__decap_3
XFILLER_53_420 VGND VGND VPWR VPWR sky130_fd_sc_hd__decap_3
XFILLER_53_442 VGND VGND VPWR VPWR sky130_fd_sc_hd__decap_3
XFILLER_82_18 VGND VGND VPWR VPWR sky130_fd_sc_hd__decap_3
XFILLER_82_29 VGND VGND VPWR VPWR sky130_fd_sc_hd__fill_1
XTAP_TAPCELL_ROW_0_254 VGND VPWR sky130_fd_sc_hd__tapvpwrvgnd_1
XTAP_TAPCELL_ROW_0_243 VGND VPWR sky130_fd_sc_hd__tapvpwrvgnd_1
XFILLER_15_12 VGND VGND VPWR VPWR sky130_fd_sc_hd__decap_3
XFILLER_25_166 VGND VGND VPWR VPWR sky130_fd_sc_hd__fill_2
XFILLER_41_604 VGND VGND VPWR VPWR sky130_fd_sc_hd__fill_2
XFILLER_15_45 VGND VGND VPWR VPWR sky130_fd_sc_hd__decap_3
XFILLER_25_199 VGND VGND VPWR VPWR sky130_fd_sc_hd__decap_3
XFILLER_40_125 VGND VGND VPWR VPWR sky130_fd_sc_hd__decap_3
XFILLER_53_486 VGND VGND VPWR VPWR sky130_fd_sc_hd__fill_1
X_6988_ _7398_/CLK _6988_/D _6268_/Y VGND VGND VPWR VPWR _6988_/Q sky130_fd_sc_hd__dfrtp_2
XTAP_TAPCELL_ROW_36_684 VGND VPWR sky130_fd_sc_hd__tapvpwrvgnd_1
XFILLER_31_33 VGND VGND VPWR VPWR sky130_fd_sc_hd__fill_1
XTAP_TAPCELL_ROW_97_1417 VGND VPWR sky130_fd_sc_hd__tapvpwrvgnd_1
XFILLER_31_55 VGND VGND VPWR VPWR sky130_fd_sc_hd__fill_1
XFILLER_31_66 VGND VGND VPWR VPWR sky130_fd_sc_hd__fill_1
XFILLER_107_433 VGND VGND VPWR VPWR sky130_fd_sc_hd__decap_3
XFILLER_103_3 VGND VGND VPWR VPWR sky130_fd_sc_hd__decap_3
XFILLER_107_466 VGND VGND VPWR VPWR sky130_fd_sc_hd__decap_3
XTAP_TAPCELL_ROW_8_343 VGND VPWR sky130_fd_sc_hd__tapvpwrvgnd_1
XFILLER_103_650 VGND VGND VPWR VPWR sky130_fd_sc_hd__decap_3
XFILLER_48_203 VGND VGND VPWR VPWR sky130_fd_sc_hd__decap_3
XFILLER_88_383 VGND VGND VPWR VPWR sky130_fd_sc_hd__decap_3
XFILLER_0_298 VGND VGND VPWR VPWR sky130_fd_sc_hd__fill_1
XFILLER_76_578 VGND VGND VPWR VPWR sky130_fd_sc_hd__decap_3
XFILLER_63_217 VGND VGND VPWR VPWR sky130_fd_sc_hd__decap_3
XFILLER_63_228 VGND VGND VPWR VPWR sky130_fd_sc_hd__decap_3
XFILLER_91_526 VGND VGND VPWR VPWR sky130_fd_sc_hd__decap_3
XFILLER_16_122 VGND VGND VPWR VPWR sky130_fd_sc_hd__decap_3
XFILLER_56_280 VGND VGND VPWR VPWR sky130_fd_sc_hd__decap_3
XFILLER_56_85 VGND VGND VPWR VPWR sky130_fd_sc_hd__fill_1
XFILLER_91_548 VGND VGND VPWR VPWR sky130_fd_sc_hd__decap_3
XTAP_TAPCELL_ROW_106_1524 VGND VPWR sky130_fd_sc_hd__tapvpwrvgnd_1
XFILLER_16_144 VGND VGND VPWR VPWR sky130_fd_sc_hd__fill_2
XFILLER_44_464 VGND VGND VPWR VPWR sky130_fd_sc_hd__decap_3
XFILLER_112_80 VGND VGND VPWR VPWR sky130_fd_sc_hd__decap_3
XFILLER_112_91 VGND VGND VPWR VPWR sky130_fd_sc_hd__decap_3
XFILLER_31_103 VGND VGND VPWR VPWR sky130_fd_sc_hd__decap_3
XFILLER_31_125 VGND VGND VPWR VPWR sky130_fd_sc_hd__decap_3
XFILLER_72_73 VGND VGND VPWR VPWR sky130_fd_sc_hd__decap_3
XFILLER_31_169 VGND VGND VPWR VPWR sky130_fd_sc_hd__decap_3
XFILLER_40_670 VGND VGND VPWR VPWR sky130_fd_sc_hd__decap_3
XFILLER_8_365 VGND VGND VPWR VPWR sky130_fd_sc_hd__decap_3
XFILLER_99_626 VGND VGND VPWR VPWR sky130_fd_sc_hd__decap_3
X_4270_ _7358_/Q _4272_/B VGND VGND VPWR VPWR _4270_/Y sky130_fd_sc_hd__nand2_2
XFILLER_99_659 VGND VGND VPWR VPWR sky130_fd_sc_hd__decap_3
XFILLER_98_125 VGND VGND VPWR VPWR sky130_fd_sc_hd__decap_3
XFILLER_98_158 VGND VGND VPWR VPWR sky130_fd_sc_hd__decap_3
XFILLER_100_119 VGND VGND VPWR VPWR sky130_fd_sc_hd__decap_3
XFILLER_39_203 VGND VGND VPWR VPWR sky130_fd_sc_hd__decap_3
XFILLER_39_225 VGND VGND VPWR VPWR sky130_fd_sc_hd__decap_3
XFILLER_67_534 VGND VGND VPWR VPWR sky130_fd_sc_hd__fill_2
XFILLER_94_320 VGND VGND VPWR VPWR sky130_fd_sc_hd__decap_3
XFILLER_67_545 VGND VGND VPWR VPWR sky130_fd_sc_hd__decap_3
XFILLER_54_206 VGND VGND VPWR VPWR sky130_fd_sc_hd__decap_3
XFILLER_67_578 VGND VGND VPWR VPWR sky130_fd_sc_hd__fill_1
XFILLER_54_239 VGND VGND VPWR VPWR sky130_fd_sc_hd__decap_3
X_6911_ _6946_/CLK _6911_/D VGND VGND VPWR VPWR _6911_/Q sky130_fd_sc_hd__dfxtp_2
XFILLER_35_442 VGND VGND VPWR VPWR sky130_fd_sc_hd__decap_3
XFILLER_35_464 VGND VGND VPWR VPWR sky130_fd_sc_hd__fill_1
XFILLER_35_475 VGND VGND VPWR VPWR sky130_fd_sc_hd__fill_2
X_6842_ _6978_/CLK _6842_/D VGND VGND VPWR VPWR _6842_/Q sky130_fd_sc_hd__dfxtp_2
XFILLER_50_401 VGND VGND VPWR VPWR sky130_fd_sc_hd__decap_3
XFILLER_62_283 VGND VGND VPWR VPWR sky130_fd_sc_hd__fill_1
XTAP_TAPCELL_ROW_81_1229 VGND VPWR sky130_fd_sc_hd__tapvpwrvgnd_1
XTAP_TAPCELL_ROW_81_1218 VGND VPWR sky130_fd_sc_hd__tapvpwrvgnd_1
X_6773_ _6970_/CLK _6773_/D VGND VGND VPWR VPWR _6773_/Q sky130_fd_sc_hd__dfxtp_2
X_3985_ _7348_/Q _4526_/A0 _3987_/S VGND VGND VPWR VPWR _7348_/D sky130_fd_sc_hd__mux2_2
XTAP_TAPCELL_ROW_33_643 VGND VPWR sky130_fd_sc_hd__tapvpwrvgnd_1
XFILLER_10_309 VGND VGND VPWR VPWR sky130_fd_sc_hd__decap_3
XFILLER_22_169 VGND VGND VPWR VPWR sky130_fd_sc_hd__decap_3
XFILLER_31_670 VGND VGND VPWR VPWR sky130_fd_sc_hd__fill_2
XTAP_TAPCELL_ROW_61_985 VGND VPWR sky130_fd_sc_hd__tapvpwrvgnd_1
XFILLER_30_180 VGND VGND VPWR VPWR sky130_fd_sc_hd__decap_3
X_5655_ _5655_/A _5655_/B _5655_/C _5655_/D VGND VGND VPWR VPWR _5665_/B sky130_fd_sc_hd__nor4_2
X_4606_ _5666_/A _5633_/B VGND VGND VPWR VPWR _4606_/Y sky130_fd_sc_hd__nor2_1
XFILLER_7_90 VGND VGND VPWR VPWR sky130_fd_sc_hd__decap_3
X_7325_ _7360_/CLK _7325_/D _6605_/Y VGND VGND VPWR VPWR _7325_/Q sky130_fd_sc_hd__dfrtp_2
X_5586_ hold970/X _5595_/B _5118_/X VGND VGND VPWR VPWR _7035_/D sky130_fd_sc_hd__o21a_2
XFILLER_116_274 VGND VGND VPWR VPWR sky130_fd_sc_hd__decap_3
X_4537_ _5118_/A _4537_/B _4537_/C VGND VGND VPWR VPWR _4577_/B sky130_fd_sc_hd__or3_2
XFILLER_77_18 VGND VGND VPWR VPWR sky130_fd_sc_hd__decap_3
X_7256_ clkload8/A _7256_/D _6536_/Y VGND VGND VPWR VPWR _7256_/Q sky130_fd_sc_hd__dfrtp_2
X_4468_ _7009_/Q _5152_/B _5595_/B VGND VGND VPWR VPWR _4468_/X sky130_fd_sc_hd__o21a_2
XTAP_TAPCELL_ROW_92_1358 VGND VPWR sky130_fd_sc_hd__tapvpwrvgnd_1
XFILLER_77_29 VGND VGND VPWR VPWR sky130_fd_sc_hd__decap_3
XFILLER_89_169 VGND VGND VPWR VPWR sky130_fd_sc_hd__fill_2
X_7187_ _7384_/CLK _7187_/D _6467_/Y VGND VGND VPWR VPWR _7187_/Q sky130_fd_sc_hd__dfrtp_2
X_3419_ _7123_/Q _3407_/X _3413_/X _3418_/X VGND VGND VPWR VPWR _3419_/Y sky130_fd_sc_hd__a211oi_2
XTAP_TAPCELL_ROW_5_313 VGND VPWR sky130_fd_sc_hd__tapvpwrvgnd_1
XFILLER_100_620 VGND VGND VPWR VPWR sky130_fd_sc_hd__decap_3
XFILLER_112_480 VGND VGND VPWR VPWR sky130_fd_sc_hd__decap_3
XFILLER_58_512 VGND VGND VPWR VPWR sky130_fd_sc_hd__decap_3
X_4399_ _7370_/Q _4429_/B1 _4398_/X _4429_/C1 VGND VGND VPWR VPWR _4399_/X sky130_fd_sc_hd__a211o_2
XFILLER_98_681 VGND VGND VPWR VPWR sky130_fd_sc_hd__decap_3
XFILLER_85_320 VGND VGND VPWR VPWR sky130_fd_sc_hd__decap_3
Xhold1010 _7383_/Q VGND VGND VPWR VPWR _3875_/A1 sky130_fd_sc_hd__dlygate4sd3_1
Xhold1021 _7037_/Q VGND VGND VPWR VPWR _5583_/A0 sky130_fd_sc_hd__dlygate4sd3_1
Xhold1032 _7238_/Q VGND VGND VPWR VPWR _5179_/A sky130_fd_sc_hd__dlygate4sd3_1
XFILLER_100_675 VGND VGND VPWR VPWR sky130_fd_sc_hd__decap_3
XFILLER_45_206 VGND VGND VPWR VPWR sky130_fd_sc_hd__decap_3
XFILLER_58_578 VGND VGND VPWR VPWR sky130_fd_sc_hd__decap_3
XFILLER_58_589 VGND VGND VPWR VPWR sky130_fd_sc_hd__decap_3
XFILLER_73_515 VGND VGND VPWR VPWR sky130_fd_sc_hd__fill_2
XFILLER_85_386 VGND VGND VPWR VPWR sky130_fd_sc_hd__decap_3
Xhold1043 _7403_/Q VGND VGND VPWR VPWR _3693_/A0 sky130_fd_sc_hd__dlygate4sd3_1
Xhold1054 _7206_/Q VGND VGND VPWR VPWR _5247_/A0 sky130_fd_sc_hd__dlygate4sd3_1
Xhold1065 _7013_/Q VGND VGND VPWR VPWR _5630_/A sky130_fd_sc_hd__dlygate4sd3_1
Xhold1076 _7293_/Q VGND VGND VPWR VPWR _4575_/A sky130_fd_sc_hd__dlygate4sd3_1
XFILLER_45_228 VGND VGND VPWR VPWR sky130_fd_sc_hd__decap_3
XFILLER_73_548 VGND VGND VPWR VPWR sky130_fd_sc_hd__decap_3
Xhold1087 _7232_/Q VGND VGND VPWR VPWR _5192_/A sky130_fd_sc_hd__dlygate4sd3_1
Xhold1098 _7310_/Q VGND VGND VPWR VPWR _4540_/A sky130_fd_sc_hd__dlygate4sd3_1
XFILLER_26_464 VGND VGND VPWR VPWR sky130_fd_sc_hd__fill_1
XFILLER_14_648 VGND VGND VPWR VPWR sky130_fd_sc_hd__decap_3
XFILLER_26_88 VGND VGND VPWR VPWR sky130_fd_sc_hd__decap_3
XFILLER_41_412 VGND VGND VPWR VPWR sky130_fd_sc_hd__decap_3
XFILLER_53_261 VGND VGND VPWR VPWR sky130_fd_sc_hd__decap_3
XFILLER_81_570 VGND VGND VPWR VPWR sky130_fd_sc_hd__decap_3
XFILLER_13_169 VGND VGND VPWR VPWR sky130_fd_sc_hd__fill_1
XFILLER_41_478 VGND VGND VPWR VPWR sky130_fd_sc_hd__fill_1
XFILLER_42_21 VGND VGND VPWR VPWR sky130_fd_sc_hd__decap_3
XFILLER_42_43 VGND VGND VPWR VPWR sky130_fd_sc_hd__decap_3
XTAP_TAPCELL_ROW_101_1465 VGND VPWR sky130_fd_sc_hd__tapvpwrvgnd_1
XFILLER_3_15 VGND VGND VPWR VPWR sky130_fd_sc_hd__decap_3
XFILLER_68_309 VGND VGND VPWR VPWR sky130_fd_sc_hd__decap_3
XFILLER_96_629 VGND VGND VPWR VPWR sky130_fd_sc_hd__decap_3
XFILLER_1_585 VGND VGND VPWR VPWR sky130_fd_sc_hd__decap_3
XFILLER_3_48 VGND VGND VPWR VPWR sky130_fd_sc_hd__decap_3
XFILLER_49_501 VGND VGND VPWR VPWR sky130_fd_sc_hd__decap_3
XFILLER_67_51 VGND VGND VPWR VPWR sky130_fd_sc_hd__decap_3
XTAP_TAPCELL_ROW_112_1594 VGND VPWR sky130_fd_sc_hd__tapvpwrvgnd_1
XFILLER_49_556 VGND VGND VPWR VPWR sky130_fd_sc_hd__decap_3
XFILLER_36_206 VGND VGND VPWR VPWR sky130_fd_sc_hd__decap_3
XFILLER_64_526 VGND VGND VPWR VPWR sky130_fd_sc_hd__decap_3
XFILLER_76_375 VGND VGND VPWR VPWR sky130_fd_sc_hd__decap_3
XFILLER_36_239 VGND VGND VPWR VPWR sky130_fd_sc_hd__decap_3
XFILLER_91_323 VGND VGND VPWR VPWR sky130_fd_sc_hd__decap_3
XFILLER_51_209 VGND VGND VPWR VPWR sky130_fd_sc_hd__decap_3
XTAP_TAPCELL_ROW_67_1051 VGND VPWR sky130_fd_sc_hd__tapvpwrvgnd_1
XPHY_EDGE_ROW_103_Left_220 VGND VGND VPWR VPWR sky130_fd_sc_hd__decap_3
XFILLER_32_401 VGND VGND VPWR VPWR sky130_fd_sc_hd__decap_3
XFILLER_72_570 VGND VGND VPWR VPWR sky130_fd_sc_hd__decap_3
XFILLER_72_592 VGND VGND VPWR VPWR sky130_fd_sc_hd__decap_3
XFILLER_32_456 VGND VGND VPWR VPWR sky130_fd_sc_hd__decap_3
X_3770_ _3770_/A1 _4791_/A1 _4944_/B VGND VGND VPWR VPWR _7393_/D sky130_fd_sc_hd__a21o_2
XTAP_TAPCELL_ROW_30_613 VGND VPWR sky130_fd_sc_hd__tapvpwrvgnd_1
XFILLER_8_162 VGND VGND VPWR VPWR sky130_fd_sc_hd__decap_3
XFILLER_9_685 VGND VGND VPWR VPWR sky130_fd_sc_hd__decap_3
XFILLER_9_663 VGND VGND VPWR VPWR sky130_fd_sc_hd__decap_3
XFILLER_66_3 VGND VGND VPWR VPWR sky130_fd_sc_hd__decap_3
XFILLER_8_184 VGND VGND VPWR VPWR sky130_fd_sc_hd__decap_3
XTAP_TAPCELL_ROW_10_370 VGND VPWR sky130_fd_sc_hd__tapvpwrvgnd_1
X_5371_ _5371_/A0 _4771_/X _5386_/S VGND VGND VPWR VPWR _7147_/D sky130_fd_sc_hd__mux2_2
XFILLER_113_211 VGND VGND VPWR VPWR sky130_fd_sc_hd__decap_3
X_7110_ _7334_/CLK _7110_/D _6390_/Y VGND VGND VPWR VPWR _7110_/Q sky130_fd_sc_hd__dfrtp_2
X_4322_ _7290_/Q _5159_/S _3409_/X _7162_/Q _4321_/X VGND VGND VPWR VPWR _4322_/X
+ sky130_fd_sc_hd__a221o_2
XTAP_TAPCELL_ROW_78_1191 VGND VPWR sky130_fd_sc_hd__tapvpwrvgnd_1
XFILLER_99_445 VGND VGND VPWR VPWR sky130_fd_sc_hd__decap_3
XFILLER_113_255 VGND VGND VPWR VPWR sky130_fd_sc_hd__decap_3
XFILLER_59_309 VGND VGND VPWR VPWR sky130_fd_sc_hd__decap_3
X_7041_ _7390_/CLK _7041_/D _6321_/Y VGND VGND VPWR VPWR _7041_/Q sky130_fd_sc_hd__dfrtp_2
X_4253_ _7389_/Q _3380_/Y _4946_/S _7293_/Q _4252_/X VGND VGND VPWR VPWR _4253_/X
+ sky130_fd_sc_hd__a221o_2
XFILLER_86_106 VGND VGND VPWR VPWR sky130_fd_sc_hd__decap_3
XFILLER_86_128 VGND VGND VPWR VPWR sky130_fd_sc_hd__decap_3
XFILLER_87_629 VGND VGND VPWR VPWR sky130_fd_sc_hd__decap_3
XFILLER_99_489 VGND VGND VPWR VPWR sky130_fd_sc_hd__decap_3
X_4184_ _7296_/Q _5028_/S _4250_/A2 _7104_/Q _4183_/X VGND VGND VPWR VPWR _4185_/C
+ sky130_fd_sc_hd__a221o_2
XFILLER_95_662 VGND VGND VPWR VPWR sky130_fd_sc_hd__decap_3
XFILLER_95_673 VGND VGND VPWR VPWR sky130_fd_sc_hd__decap_3
XTAP_TAPCELL_ROW_38_713 VGND VPWR sky130_fd_sc_hd__tapvpwrvgnd_1
XTAP_TAPCELL_ROW_38_702 VGND VPWR sky130_fd_sc_hd__tapvpwrvgnd_1
XFILLER_103_27 VGND VGND VPWR VPWR sky130_fd_sc_hd__decap_3
XFILLER_103_49 VGND VGND VPWR VPWR sky130_fd_sc_hd__decap_3
XFILLER_27_228 VGND VGND VPWR VPWR sky130_fd_sc_hd__decap_3
XFILLER_67_386 VGND VGND VPWR VPWR sky130_fd_sc_hd__decap_3
XFILLER_82_312 VGND VGND VPWR VPWR sky130_fd_sc_hd__decap_3
XFILLER_94_194 VGND VGND VPWR VPWR sky130_fd_sc_hd__fill_2
XFILLER_82_356 VGND VGND VPWR VPWR sky130_fd_sc_hd__decap_3
XFILLER_23_401 VGND VGND VPWR VPWR sky130_fd_sc_hd__fill_1
XFILLER_63_592 VGND VGND VPWR VPWR sky130_fd_sc_hd__decap_3
XTAP_TAPCELL_ROW_18_470 VGND VPWR sky130_fd_sc_hd__tapvpwrvgnd_1
XFILLER_50_231 VGND VGND VPWR VPWR sky130_fd_sc_hd__decap_3
X_6825_ _6970_/CLK _6825_/D VGND VGND VPWR VPWR _6825_/Q sky130_fd_sc_hd__dfxtp_2
XFILLER_10_106 VGND VGND VPWR VPWR sky130_fd_sc_hd__decap_3
XFILLER_11_607 VGND VGND VPWR VPWR sky130_fd_sc_hd__fill_1
XFILLER_23_489 VGND VGND VPWR VPWR sky130_fd_sc_hd__decap_3
XFILLER_50_253 VGND VGND VPWR VPWR sky130_fd_sc_hd__decap_3
X_6756_ _6971_/CLK _6756_/D VGND VGND VPWR VPWR _6756_/Q sky130_fd_sc_hd__dfxtp_2
X_3968_ _7356_/Q _4510_/A0 _3968_/S VGND VGND VPWR VPWR _7356_/D sky130_fd_sc_hd__mux2_2
XFILLER_10_139 VGND VGND VPWR VPWR sky130_fd_sc_hd__fill_1
XFILLER_50_286 VGND VGND VPWR VPWR sky130_fd_sc_hd__decap_3
XFILLER_109_539 VGND VGND VPWR VPWR sky130_fd_sc_hd__decap_3
XFILLER_12_24 VGND VGND VPWR VPWR sky130_fd_sc_hd__decap_3
XFILLER_12_35 VGND VGND VPWR VPWR sky130_fd_sc_hd__decap_3
X_6687_ _7383_/CLK _6687_/D VGND VGND VPWR VPWR _6687_/Q sky130_fd_sc_hd__dfxtp_2
X_3899_ _6693_/Q _5660_/B _3917_/B1 _6871_/Q _3746_/C VGND VGND VPWR VPWR _3899_/X
+ sky130_fd_sc_hd__a221o_2
XFILLER_12_68 VGND VGND VPWR VPWR sky130_fd_sc_hd__decap_3
XFILLER_2_305 VGND VGND VPWR VPWR sky130_fd_sc_hd__decap_3
X_5569_ hold986/X _4909_/A _4910_/B VGND VGND VPWR VPWR _7048_/D sky130_fd_sc_hd__a21bo_2
XFILLER_104_200 VGND VGND VPWR VPWR sky130_fd_sc_hd__fill_1
XFILLER_2_327 VGND VGND VPWR VPWR sky130_fd_sc_hd__decap_3
XFILLER_88_39 VGND VGND VPWR VPWR sky130_fd_sc_hd__decap_3
X_7308_ _7310_/CLK _7308_/D _6588_/Y VGND VGND VPWR VPWR _7308_/Q sky130_fd_sc_hd__dfrtp_2
XFILLER_104_244 VGND VGND VPWR VPWR sky130_fd_sc_hd__decap_3
X_7239_ _7337_/CLK _7239_/D _6519_/Y VGND VGND VPWR VPWR _7239_/Q sky130_fd_sc_hd__dfrtp_2
XFILLER_104_299 VGND VGND VPWR VPWR sky130_fd_sc_hd__decap_3
XFILLER_58_342 VGND VGND VPWR VPWR sky130_fd_sc_hd__decap_3
XFILLER_86_651 VGND VGND VPWR VPWR sky130_fd_sc_hd__decap_3
XFILLER_37_21 VGND VGND VPWR VPWR sky130_fd_sc_hd__decap_3
XFILLER_58_353 VGND VGND VPWR VPWR sky130_fd_sc_hd__decap_3
XFILLER_86_684 VGND VGND VPWR VPWR sky130_fd_sc_hd__decap_3
XFILLER_92_109 VGND VGND VPWR VPWR sky130_fd_sc_hd__decap_3
XFILLER_100_472 VGND VGND VPWR VPWR sky130_fd_sc_hd__decap_3
XFILLER_18_217 VGND VGND VPWR VPWR sky130_fd_sc_hd__decap_3
XFILLER_37_54 VGND VGND VPWR VPWR sky130_fd_sc_hd__fill_2
XFILLER_37_76 VGND VGND VPWR VPWR sky130_fd_sc_hd__decap_3
XFILLER_85_172 VGND VGND VPWR VPWR sky130_fd_sc_hd__decap_3
XFILLER_14_445 VGND VGND VPWR VPWR sky130_fd_sc_hd__fill_2
XFILLER_26_283 VGND VGND VPWR VPWR sky130_fd_sc_hd__fill_1
XFILLER_41_220 VGND VGND VPWR VPWR sky130_fd_sc_hd__decap_3
XFILLER_41_231 VGND VGND VPWR VPWR sky130_fd_sc_hd__fill_1
XFILLER_53_42 VGND VGND VPWR VPWR sky130_fd_sc_hd__decap_3
XFILLER_54_592 VGND VGND VPWR VPWR sky130_fd_sc_hd__decap_3
XFILLER_53_64 VGND VGND VPWR VPWR sky130_fd_sc_hd__fill_2
XFILLER_53_86 VGND VGND VPWR VPWR sky130_fd_sc_hd__decap_3
XFILLER_10_662 VGND VGND VPWR VPWR sky130_fd_sc_hd__decap_3
XFILLER_6_622 VGND VGND VPWR VPWR sky130_fd_sc_hd__decap_3
XFILLER_5_143 VGND VGND VPWR VPWR sky130_fd_sc_hd__decap_3
XFILLER_6_688 VGND VGND VPWR VPWR sky130_fd_sc_hd__decap_3
XTAP_TAPCELL_ROW_114_1623 VGND VPWR sky130_fd_sc_hd__tapvpwrvgnd_1
XFILLER_110_203 VGND VGND VPWR VPWR sky130_fd_sc_hd__decap_3
XFILLER_68_106 VGND VGND VPWR VPWR sky130_fd_sc_hd__decap_3
XFILLER_69_629 VGND VGND VPWR VPWR sky130_fd_sc_hd__decap_3
XFILLER_78_83 VGND VGND VPWR VPWR sky130_fd_sc_hd__fill_1
XFILLER_110_247 VGND VGND VPWR VPWR sky130_fd_sc_hd__decap_3
XFILLER_1_382 VGND VGND VPWR VPWR sky130_fd_sc_hd__decap_3
XFILLER_1_393 VGND VGND VPWR VPWR sky130_fd_sc_hd__decap_3
XFILLER_49_331 VGND VGND VPWR VPWR sky130_fd_sc_hd__fill_1
XFILLER_68_139 VGND VGND VPWR VPWR sky130_fd_sc_hd__fill_1
XFILLER_77_651 VGND VGND VPWR VPWR sky130_fd_sc_hd__decap_3
XFILLER_76_150 VGND VGND VPWR VPWR sky130_fd_sc_hd__decap_3
XFILLER_77_673 VGND VGND VPWR VPWR sky130_fd_sc_hd__decap_3
XFILLER_64_334 VGND VGND VPWR VPWR sky130_fd_sc_hd__decap_3
XFILLER_92_632 VGND VGND VPWR VPWR sky130_fd_sc_hd__decap_3
XFILLER_24_209 VGND VGND VPWR VPWR sky130_fd_sc_hd__decap_3
XFILLER_91_131 VGND VGND VPWR VPWR sky130_fd_sc_hd__decap_3
XFILLER_92_654 VGND VGND VPWR VPWR sky130_fd_sc_hd__decap_3
XFILLER_17_261 VGND VGND VPWR VPWR sky130_fd_sc_hd__fill_2
XFILLER_17_272 VGND VGND VPWR VPWR sky130_fd_sc_hd__decap_3
XFILLER_92_687 VGND VGND VPWR VPWR sky130_fd_sc_hd__decap_3
X_4940_ _4814_/A _4937_/Y _4939_/X VGND VGND VPWR VPWR _4940_/Y sky130_fd_sc_hd__o21ai_2
XFILLER_32_231 VGND VGND VPWR VPWR sky130_fd_sc_hd__decap_3
X_4871_ _4845_/A _4643_/Y _4841_/Y _4948_/A VGND VGND VPWR VPWR _4871_/Y sky130_fd_sc_hd__a31oi_2
XFILLER_32_253 VGND VGND VPWR VPWR sky130_fd_sc_hd__fill_1
XFILLER_60_573 VGND VGND VPWR VPWR sky130_fd_sc_hd__decap_3
X_6610_ _6610_/A VGND VGND VPWR VPWR _6610_/Y sky130_fd_sc_hd__inv_2
X_3822_ hold989/X _4466_/A _5010_/C VGND VGND VPWR VPWR _7389_/D sky130_fd_sc_hd__a21o_2
XTAP_TAPCELL_ROW_43_771 VGND VPWR sky130_fd_sc_hd__tapvpwrvgnd_1
XFILLER_60_595 VGND VGND VPWR VPWR sky130_fd_sc_hd__decap_3
X_6541_ _6604_/A VGND VGND VPWR VPWR _6541_/Y sky130_fd_sc_hd__inv_2
X_3753_ _3629_/A _3752_/X _5104_/A VGND VGND VPWR VPWR _3753_/X sky130_fd_sc_hd__a21o_2
X_6472_ _6634_/A VGND VGND VPWR VPWR _6472_/Y sky130_fd_sc_hd__inv_2
X_3684_ _3684_/A1 _3442_/A _3683_/Y VGND VGND VPWR VPWR _7404_/D sky130_fd_sc_hd__a21bo_2
X_5423_ _5423_/A0 _5139_/X _5423_/S VGND VGND VPWR VPWR _7122_/D sky130_fd_sc_hd__mux2_2
X_5354_ _5354_/A0 _5139_/X _5358_/S VGND VGND VPWR VPWR _7154_/D sky130_fd_sc_hd__mux2_2
XFILLER_114_531 VGND VGND VPWR VPWR sky130_fd_sc_hd__fill_1
XFILLER_114_542 VGND VGND VPWR VPWR sky130_fd_sc_hd__decap_3
X_4305_ _7064_/Q _4305_/B VGND VGND VPWR VPWR _4364_/B sky130_fd_sc_hd__nor2_2
XFILLER_99_242 VGND VGND VPWR VPWR sky130_fd_sc_hd__decap_3
XFILLER_114_575 VGND VGND VPWR VPWR sky130_fd_sc_hd__decap_3
XFILLER_87_426 VGND VGND VPWR VPWR sky130_fd_sc_hd__decap_3
XFILLER_99_275 VGND VGND VPWR VPWR sky130_fd_sc_hd__decap_3
XFILLER_101_225 VGND VGND VPWR VPWR sky130_fd_sc_hd__decap_3
XFILLER_114_15 VGND VGND VPWR VPWR sky130_fd_sc_hd__decap_3
XFILLER_4_80 VGND VGND VPWR VPWR sky130_fd_sc_hd__decap_3
XFILLER_4_91 VGND VGND VPWR VPWR sky130_fd_sc_hd__decap_3
X_7024_ _7402_/CLK _7024_/D _6304_/Y VGND VGND VPWR VPWR _7024_/Q sky130_fd_sc_hd__dfrtp_2
X_4236_ _7163_/Q _4339_/B1 _4234_/X _4235_/X VGND VGND VPWR VPWR _4236_/X sky130_fd_sc_hd__a211o_2
XFILLER_101_258 VGND VGND VPWR VPWR sky130_fd_sc_hd__decap_3
XFILLER_28_515 VGND VGND VPWR VPWR sky130_fd_sc_hd__decap_3
XFILLER_68_651 VGND VGND VPWR VPWR sky130_fd_sc_hd__decap_3
XFILLER_83_610 VGND VGND VPWR VPWR sky130_fd_sc_hd__decap_3
X_4167_ _7393_/Q _4429_/B1 _4417_/A2 _7297_/Q _4166_/X VGND VGND VPWR VPWR _4167_/X
+ sky130_fd_sc_hd__a221o_2
XFILLER_114_59 VGND VGND VPWR VPWR sky130_fd_sc_hd__decap_3
XFILLER_55_312 VGND VGND VPWR VPWR sky130_fd_sc_hd__decap_3
XFILLER_83_632 VGND VGND VPWR VPWR sky130_fd_sc_hd__decap_3
XFILLER_28_559 VGND VGND VPWR VPWR sky130_fd_sc_hd__fill_2
XFILLER_82_153 VGND VGND VPWR VPWR sky130_fd_sc_hd__fill_1
XFILLER_83_665 VGND VGND VPWR VPWR sky130_fd_sc_hd__decap_3
XFILLER_83_676 VGND VGND VPWR VPWR sky130_fd_sc_hd__decap_3
X_4098_ _7333_/Q _3954_/S _4419_/B1 _7365_/Q _4248_/A VGND VGND VPWR VPWR _4098_/X
+ sky130_fd_sc_hd__a221o_2
XFILLER_55_378 VGND VGND VPWR VPWR sky130_fd_sc_hd__decap_3
XFILLER_82_197 VGND VGND VPWR VPWR sky130_fd_sc_hd__decap_3
XFILLER_23_12 VGND VGND VPWR VPWR sky130_fd_sc_hd__decap_3
XFILLER_23_264 VGND VGND VPWR VPWR sky130_fd_sc_hd__decap_3
X_6808_ _6944_/CLK _6808_/D VGND VGND VPWR VPWR _6808_/Q sky130_fd_sc_hd__dfxtp_2
XFILLER_23_45 VGND VGND VPWR VPWR sky130_fd_sc_hd__decap_3
XFILLER_23_78 VGND VGND VPWR VPWR sky130_fd_sc_hd__decap_3
X_6739_ _6970_/CLK _6739_/D VGND VGND VPWR VPWR _6739_/Q sky130_fd_sc_hd__dfxtp_2
XTAP_TAPCELL_ROW_21_498 VGND VPWR sky130_fd_sc_hd__tapvpwrvgnd_1
XFILLER_3_614 VGND VGND VPWR VPWR sky130_fd_sc_hd__fill_2
XFILLER_3_625 VGND VGND VPWR VPWR sky130_fd_sc_hd__decap_3
XFILLER_105_531 VGND VGND VPWR VPWR sky130_fd_sc_hd__decap_3
XFILLER_2_124 VGND VGND VPWR VPWR sky130_fd_sc_hd__decap_3
XFILLER_3_658 VGND VGND VPWR VPWR sky130_fd_sc_hd__decap_3
XFILLER_105_564 VGND VGND VPWR VPWR sky130_fd_sc_hd__decap_3
XFILLER_78_404 VGND VGND VPWR VPWR sky130_fd_sc_hd__decap_3
XFILLER_48_42 VGND VGND VPWR VPWR sky130_fd_sc_hd__decap_3
XFILLER_78_437 VGND VGND VPWR VPWR sky130_fd_sc_hd__fill_1
XFILLER_48_75 VGND VGND VPWR VPWR sky130_fd_sc_hd__decap_3
XFILLER_58_150 VGND VGND VPWR VPWR sky130_fd_sc_hd__decap_3
XFILLER_59_662 VGND VGND VPWR VPWR sky130_fd_sc_hd__decap_3
XFILLER_59_673 VGND VGND VPWR VPWR sky130_fd_sc_hd__decap_3
XFILLER_93_429 VGND VGND VPWR VPWR sky130_fd_sc_hd__decap_3
XFILLER_46_312 VGND VGND VPWR VPWR sky130_fd_sc_hd__decap_3
XFILLER_48_97 VGND VGND VPWR VPWR sky130_fd_sc_hd__fill_1
XFILLER_74_610 VGND VGND VPWR VPWR sky130_fd_sc_hd__fill_1
XFILLER_74_632 VGND VGND VPWR VPWR sky130_fd_sc_hd__decap_3
XFILLER_0_38 VGND VGND VPWR VPWR sky130_fd_sc_hd__decap_3
XFILLER_100_291 VGND VGND VPWR VPWR sky130_fd_sc_hd__decap_3
XFILLER_19_559 VGND VGND VPWR VPWR sky130_fd_sc_hd__fill_1
XFILLER_73_142 VGND VGND VPWR VPWR sky130_fd_sc_hd__decap_3
XFILLER_74_654 VGND VGND VPWR VPWR sky130_fd_sc_hd__decap_3
XFILLER_61_304 VGND VGND VPWR VPWR sky130_fd_sc_hd__decap_3
XFILLER_64_52 VGND VGND VPWR VPWR sky130_fd_sc_hd__decap_3
XFILLER_74_687 VGND VGND VPWR VPWR sky130_fd_sc_hd__decap_3
XFILLER_61_337 VGND VGND VPWR VPWR sky130_fd_sc_hd__decap_3
XFILLER_64_85 VGND VGND VPWR VPWR sky130_fd_sc_hd__decap_3
XTAP_TAPCELL_ROW_64_1021 VGND VPWR sky130_fd_sc_hd__tapvpwrvgnd_1
XTAP_TAPCELL_ROW_29_598 VGND VPWR sky130_fd_sc_hd__tapvpwrvgnd_1
XFILLER_14_242 VGND VGND VPWR VPWR sky130_fd_sc_hd__decap_3
XFILLER_14_253 VGND VGND VPWR VPWR sky130_fd_sc_hd__decap_3
XFILLER_9_36 VGND VGND VPWR VPWR sky130_fd_sc_hd__decap_3
XFILLER_9_69 VGND VGND VPWR VPWR sky130_fd_sc_hd__decap_3
XFILLER_80_62 VGND VGND VPWR VPWR sky130_fd_sc_hd__decap_3
XTAP_TAPCELL_ROW_40_730 VGND VPWR sky130_fd_sc_hd__tapvpwrvgnd_1
XFILLER_6_430 VGND VGND VPWR VPWR sky130_fd_sc_hd__decap_3
XFILLER_6_463 VGND VGND VPWR VPWR sky130_fd_sc_hd__decap_3
Xhold909 _5686_/X VGND VGND VPWR VPWR _6693_/D sky130_fd_sc_hd__dlygate4sd3_1
XFILLER_115_328 VGND VGND VPWR VPWR sky130_fd_sc_hd__decap_3
XFILLER_50_6 VGND VGND VPWR VPWR sky130_fd_sc_hd__decap_3
XFILLER_89_60 VGND VGND VPWR VPWR sky130_fd_sc_hd__fill_2
XTAP_TAPCELL_ROW_75_1150 VGND VPWR sky130_fd_sc_hd__tapvpwrvgnd_1
XFILLER_111_545 VGND VGND VPWR VPWR sky130_fd_sc_hd__decap_3
X_5070_ _5073_/A _5050_/X _5053_/Y VGND VGND VPWR VPWR _5075_/A sky130_fd_sc_hd__o21a_2
XFILLER_111_567 VGND VGND VPWR VPWR sky130_fd_sc_hd__decap_3
XFILLER_29_3 VGND VGND VPWR VPWR sky130_fd_sc_hd__decap_3
XFILLER_49_150 VGND VGND VPWR VPWR sky130_fd_sc_hd__fill_1
XFILLER_84_418 VGND VGND VPWR VPWR sky130_fd_sc_hd__fill_2
XFILLER_96_278 VGND VGND VPWR VPWR sky130_fd_sc_hd__decap_3
XFILLER_49_172 VGND VGND VPWR VPWR sky130_fd_sc_hd__decap_3
XFILLER_65_632 VGND VGND VPWR VPWR sky130_fd_sc_hd__decap_3
XFILLER_77_492 VGND VGND VPWR VPWR sky130_fd_sc_hd__decap_3
XTAP_TAPCELL_ROW_48_830 VGND VPWR sky130_fd_sc_hd__tapvpwrvgnd_1
XFILLER_37_345 VGND VGND VPWR VPWR sky130_fd_sc_hd__decap_3
XFILLER_65_665 VGND VGND VPWR VPWR sky130_fd_sc_hd__decap_3
XFILLER_65_676 VGND VGND VPWR VPWR sky130_fd_sc_hd__decap_3
XFILLER_92_451 VGND VGND VPWR VPWR sky130_fd_sc_hd__fill_2
XFILLER_52_304 VGND VGND VPWR VPWR sky130_fd_sc_hd__decap_3
XFILLER_52_315 VGND VGND VPWR VPWR sky130_fd_sc_hd__decap_3
XFILLER_64_153 VGND VGND VPWR VPWR sky130_fd_sc_hd__fill_2
XFILLER_80_624 VGND VGND VPWR VPWR sky130_fd_sc_hd__decap_3
XFILLER_52_359 VGND VGND VPWR VPWR sky130_fd_sc_hd__decap_3
XFILLER_64_197 VGND VGND VPWR VPWR sky130_fd_sc_hd__decap_3
XFILLER_80_657 VGND VGND VPWR VPWR sky130_fd_sc_hd__decap_3
X_4923_ _4920_/A _4922_/X _4969_/B VGND VGND VPWR VPWR _4923_/Y sky130_fd_sc_hd__o21ai_2
XFILLER_20_223 VGND VGND VPWR VPWR sky130_fd_sc_hd__decap_3
X_4854_ _4764_/B _4096_/A _4633_/A _5101_/A VGND VGND VPWR VPWR _4854_/X sky130_fd_sc_hd__o22a_2
XFILLER_20_245 VGND VGND VPWR VPWR sky130_fd_sc_hd__decap_3
XFILLER_20_256 VGND VGND VPWR VPWR sky130_fd_sc_hd__decap_3
X_4785_ _4785_/A _4811_/B VGND VGND VPWR VPWR _4795_/B sky130_fd_sc_hd__nand2_2
X_3805_ _6948_/Q _3913_/B1 _3912_/B1 _6960_/Q VGND VGND VPWR VPWR _3805_/X sky130_fd_sc_hd__a22o_2
XFILLER_20_289 VGND VGND VPWR VPWR sky130_fd_sc_hd__decap_3
X_6524_ _6647_/A VGND VGND VPWR VPWR _6524_/Y sky130_fd_sc_hd__inv_2
XFILLER_109_15 VGND VGND VPWR VPWR sky130_fd_sc_hd__decap_3
XFILLER_9_290 VGND VGND VPWR VPWR sky130_fd_sc_hd__fill_1
XFILLER_106_317 VGND VGND VPWR VPWR sky130_fd_sc_hd__fill_2
XFILLER_109_48 VGND VGND VPWR VPWR sky130_fd_sc_hd__decap_3
X_6455_ _6584_/A VGND VGND VPWR VPWR _6455_/Y sky130_fd_sc_hd__inv_2
X_6386_ _6547_/A VGND VGND VPWR VPWR _6386_/Y sky130_fd_sc_hd__inv_2
X_3598_ _3598_/A _3611_/B VGND VGND VPWR VPWR _4614_/B sky130_fd_sc_hd__nor2_2
XFILLER_0_606 VGND VGND VPWR VPWR sky130_fd_sc_hd__decap_3
XFILLER_0_617 VGND VGND VPWR VPWR sky130_fd_sc_hd__decap_3
X_5268_ _5268_/A0 _5027_/X _5274_/S VGND VGND VPWR VPWR _7196_/D sky130_fd_sc_hd__mux2_2
XFILLER_102_567 VGND VGND VPWR VPWR sky130_fd_sc_hd__decap_3
XFILLER_102_589 VGND VGND VPWR VPWR sky130_fd_sc_hd__fill_2
XFILLER_85_29 VGND VGND VPWR VPWR sky130_fd_sc_hd__decap_3
XFILLER_87_278 VGND VGND VPWR VPWR sky130_fd_sc_hd__fill_2
X_7007_ _7374_/CLK _7007_/D _6287_/Y VGND VGND VPWR VPWR _7007_/Q sky130_fd_sc_hd__dfrtp_2
X_4219_ _7292_/Q _4946_/S _4352_/B1 _7164_/Q _4218_/X VGND VGND VPWR VPWR _4219_/X
+ sky130_fd_sc_hd__a221o_2
XTAP_TAPCELL_ROW_89_1319 VGND VPWR sky130_fd_sc_hd__tapvpwrvgnd_1
XFILLER_18_12 VGND VGND VPWR VPWR sky130_fd_sc_hd__decap_3
XFILLER_28_312 VGND VGND VPWR VPWR sky130_fd_sc_hd__decap_3
XFILLER_56_610 VGND VGND VPWR VPWR sky130_fd_sc_hd__decap_3
XFILLER_18_67 VGND VGND VPWR VPWR sky130_fd_sc_hd__decap_3
XFILLER_55_142 VGND VGND VPWR VPWR sky130_fd_sc_hd__decap_3
XFILLER_56_643 VGND VGND VPWR VPWR sky130_fd_sc_hd__fill_1
XFILLER_56_654 VGND VGND VPWR VPWR sky130_fd_sc_hd__decap_3
XFILLER_16_518 VGND VGND VPWR VPWR sky130_fd_sc_hd__decap_3
XFILLER_43_326 VGND VGND VPWR VPWR sky130_fd_sc_hd__decap_3
XFILLER_71_613 VGND VGND VPWR VPWR sky130_fd_sc_hd__decap_3
XFILLER_71_635 VGND VGND VPWR VPWR sky130_fd_sc_hd__decap_3
XFILLER_43_337 VGND VGND VPWR VPWR sky130_fd_sc_hd__decap_3
XFILLER_55_186 VGND VGND VPWR VPWR sky130_fd_sc_hd__decap_3
XFILLER_70_112 VGND VGND VPWR VPWR sky130_fd_sc_hd__decap_3
XFILLER_71_668 VGND VGND VPWR VPWR sky130_fd_sc_hd__decap_3
XFILLER_24_562 VGND VGND VPWR VPWR sky130_fd_sc_hd__decap_3
XFILLER_34_44 VGND VGND VPWR VPWR sky130_fd_sc_hd__decap_3
XFILLER_34_55 VGND VGND VPWR VPWR sky130_fd_sc_hd__decap_3
XFILLER_70_156 VGND VGND VPWR VPWR sky130_fd_sc_hd__decap_3
XFILLER_71_679 VGND VGND VPWR VPWR sky130_fd_sc_hd__decap_3
XTAP_TAPCELL_ROW_26_568 VGND VPWR sky130_fd_sc_hd__tapvpwrvgnd_1
XFILLER_11_212 VGND VGND VPWR VPWR sky130_fd_sc_hd__fill_1
XFILLER_34_88 VGND VGND VPWR VPWR sky130_fd_sc_hd__decap_3
XFILLER_51_370 VGND VGND VPWR VPWR sky130_fd_sc_hd__decap_3
XFILLER_70_189 VGND VGND VPWR VPWR sky130_fd_sc_hd__decap_3
XTAP_TAPCELL_ROW_54_899 VGND VPWR sky130_fd_sc_hd__tapvpwrvgnd_1
XFILLER_11_234 VGND VGND VPWR VPWR sky130_fd_sc_hd__decap_3
XFILLER_109_111 VGND VGND VPWR VPWR sky130_fd_sc_hd__fill_1
XFILLER_109_122 VGND VGND VPWR VPWR sky130_fd_sc_hd__decap_3
XFILLER_11_267 VGND VGND VPWR VPWR sky130_fd_sc_hd__decap_3
XFILLER_109_155 VGND VGND VPWR VPWR sky130_fd_sc_hd__decap_3
XFILLER_50_43 VGND VGND VPWR VPWR sky130_fd_sc_hd__decap_3
XFILLER_109_199 VGND VGND VPWR VPWR sky130_fd_sc_hd__decap_3
XFILLER_3_411 VGND VGND VPWR VPWR sky130_fd_sc_hd__decap_3
XFILLER_3_444 VGND VGND VPWR VPWR sky130_fd_sc_hd__decap_3
XFILLER_112_309 VGND VGND VPWR VPWR sky130_fd_sc_hd__decap_3
XFILLER_3_455 VGND VGND VPWR VPWR sky130_fd_sc_hd__decap_3
XFILLER_105_383 VGND VGND VPWR VPWR sky130_fd_sc_hd__decap_3
XFILLER_59_63 VGND VGND VPWR VPWR sky130_fd_sc_hd__decap_3
XFILLER_66_418 VGND VGND VPWR VPWR sky130_fd_sc_hd__fill_2
XFILLER_15_9 VGND VGND VPWR VPWR sky130_fd_sc_hd__decap_3
XFILLER_47_610 VGND VGND VPWR VPWR sky130_fd_sc_hd__decap_3
XFILLER_47_632 VGND VGND VPWR VPWR sky130_fd_sc_hd__decap_3
XTAP_TAPCELL_ROW_70_1091 VGND VPWR sky130_fd_sc_hd__tapvpwrvgnd_1
XFILLER_47_665 VGND VGND VPWR VPWR sky130_fd_sc_hd__decap_3
XFILLER_74_440 VGND VGND VPWR VPWR sky130_fd_sc_hd__decap_3
XTAP_TAPCELL_ROW_109_1555 VGND VPWR sky130_fd_sc_hd__tapvpwrvgnd_1
XFILLER_34_315 VGND VGND VPWR VPWR sky130_fd_sc_hd__decap_3
XFILLER_46_153 VGND VGND VPWR VPWR sky130_fd_sc_hd__decap_3
XFILLER_47_676 VGND VGND VPWR VPWR sky130_fd_sc_hd__decap_3
XFILLER_62_613 VGND VGND VPWR VPWR sky130_fd_sc_hd__decap_3
XFILLER_74_462 VGND VGND VPWR VPWR sky130_fd_sc_hd__decap_3
XFILLER_75_95 VGND VGND VPWR VPWR sky130_fd_sc_hd__decap_3
XFILLER_34_348 VGND VGND VPWR VPWR sky130_fd_sc_hd__decap_3
XFILLER_46_197 VGND VGND VPWR VPWR sky130_fd_sc_hd__decap_3
XFILLER_61_134 VGND VGND VPWR VPWR sky130_fd_sc_hd__decap_3
XFILLER_62_657 VGND VGND VPWR VPWR sky130_fd_sc_hd__decap_3
XFILLER_15_540 VGND VGND VPWR VPWR sky130_fd_sc_hd__decap_3
XFILLER_61_145 VGND VGND VPWR VPWR sky130_fd_sc_hd__decap_3
XFILLER_15_573 VGND VGND VPWR VPWR sky130_fd_sc_hd__fill_1
XFILLER_70_690 VGND VGND VPWR VPWR sky130_fd_sc_hd__fill_2
XFILLER_98_6 VGND VGND VPWR VPWR sky130_fd_sc_hd__decap_3
XFILLER_30_565 VGND VGND VPWR VPWR sky130_fd_sc_hd__fill_1
XFILLER_30_576 VGND VGND VPWR VPWR sky130_fd_sc_hd__decap_3
X_3521_ _3525_/A _3525_/B VGND VGND VPWR VPWR _3618_/C sky130_fd_sc_hd__nand2_2
XFILLER_116_615 VGND VGND VPWR VPWR sky130_fd_sc_hd__fill_1
XFILLER_116_626 VGND VGND VPWR VPWR sky130_fd_sc_hd__decap_3
XFILLER_116_648 VGND VGND VPWR VPWR sky130_fd_sc_hd__decap_3
Xhold706 _6930_/Q VGND VGND VPWR VPWR _6930_/D sky130_fd_sc_hd__dlygate4sd3_1
Xhold717 _6949_/Q VGND VGND VPWR VPWR _6949_/D sky130_fd_sc_hd__dlygate4sd3_1
Xhold728 _6766_/Q VGND VGND VPWR VPWR _6766_/D sky130_fd_sc_hd__dlygate4sd3_1
XFILLER_115_125 VGND VGND VPWR VPWR sky130_fd_sc_hd__decap_3
XFILLER_115_158 VGND VGND VPWR VPWR sky130_fd_sc_hd__decap_3
Xhold739 _6730_/Q VGND VGND VPWR VPWR _6730_/D sky130_fd_sc_hd__dlygate4sd3_1
XFILLER_115_169 VGND VGND VPWR VPWR sky130_fd_sc_hd__decap_3
X_3383_ _5118_/D _3383_/B VGND VGND VPWR VPWR _3562_/A sky130_fd_sc_hd__nor2_2
XFILLER_69_223 VGND VGND VPWR VPWR sky130_fd_sc_hd__fill_1
X_5122_ _5122_/A0 _5121_/X _5136_/S VGND VGND VPWR VPWR _7254_/D sky130_fd_sc_hd__mux2_2
XFILLER_69_278 VGND VGND VPWR VPWR sky130_fd_sc_hd__fill_2
XFILLER_97_554 VGND VGND VPWR VPWR sky130_fd_sc_hd__fill_2
XFILLER_84_226 VGND VGND VPWR VPWR sky130_fd_sc_hd__decap_3
X_5053_ _5073_/A _5050_/X _3522_/Y VGND VGND VPWR VPWR _5053_/Y sky130_fd_sc_hd__a21oi_2
XFILLER_1_81 VGND VGND VPWR VPWR sky130_fd_sc_hd__decap_3
XFILLER_38_687 VGND VGND VPWR VPWR sky130_fd_sc_hd__fill_2
XFILLER_53_613 VGND VGND VPWR VPWR sky130_fd_sc_hd__decap_3
XFILLER_111_38 VGND VGND VPWR VPWR sky130_fd_sc_hd__decap_3
XFILLER_25_337 VGND VGND VPWR VPWR sky130_fd_sc_hd__decap_3
XFILLER_37_186 VGND VGND VPWR VPWR sky130_fd_sc_hd__decap_3
XFILLER_53_635 VGND VGND VPWR VPWR sky130_fd_sc_hd__decap_3
XFILLER_80_421 VGND VGND VPWR VPWR sky130_fd_sc_hd__decap_3
XFILLER_52_167 VGND VGND VPWR VPWR sky130_fd_sc_hd__fill_1
XFILLER_53_668 VGND VGND VPWR VPWR sky130_fd_sc_hd__decap_3
XFILLER_53_679 VGND VGND VPWR VPWR sky130_fd_sc_hd__decap_3
XFILLER_40_318 VGND VGND VPWR VPWR sky130_fd_sc_hd__decap_3
XFILLER_80_498 VGND VGND VPWR VPWR sky130_fd_sc_hd__decap_3
X_4906_ _4814_/A _4886_/C _4904_/X _4905_/X VGND VGND VPWR VPWR _4906_/X sky130_fd_sc_hd__o31a_2
XTAP_TAPCELL_ROW_23_527 VGND VPWR sky130_fd_sc_hd__tapvpwrvgnd_1
X_4837_ _4837_/A0 _4836_/X _4837_/S VGND VGND VPWR VPWR _7271_/D sky130_fd_sc_hd__mux2_2
XTAP_TAPCELL_ROW_51_869 VGND VPWR sky130_fd_sc_hd__tapvpwrvgnd_1
XTAP_TAPCELL_ROW_51_858 VGND VPWR sky130_fd_sc_hd__tapvpwrvgnd_1
XFILLER_107_604 VGND VGND VPWR VPWR sky130_fd_sc_hd__decap_3
X_4768_ _4762_/Y _4763_/X _4767_/X VGND VGND VPWR VPWR _4768_/Y sky130_fd_sc_hd__o21ai_2
XFILLER_106_103 VGND VGND VPWR VPWR sky130_fd_sc_hd__decap_3
XFILLER_107_626 VGND VGND VPWR VPWR sky130_fd_sc_hd__decap_3
XFILLER_20_24 VGND VGND VPWR VPWR sky130_fd_sc_hd__decap_3
X_6507_ _6532_/A VGND VGND VPWR VPWR _6507_/Y sky130_fd_sc_hd__inv_2
X_4699_ _6986_/Q _6987_/Q _5098_/A VGND VGND VPWR VPWR _5066_/A sky130_fd_sc_hd__and3_2
XFILLER_107_659 VGND VGND VPWR VPWR sky130_fd_sc_hd__decap_3
XFILLER_20_46 VGND VGND VPWR VPWR sky130_fd_sc_hd__decap_3
X_6438_ _6532_/A VGND VGND VPWR VPWR _6438_/Y sky130_fd_sc_hd__inv_2
XFILLER_20_79 VGND VGND VPWR VPWR sky130_fd_sc_hd__decap_3
XFILLER_96_17 VGND VGND VPWR VPWR sky130_fd_sc_hd__decap_3
XTAP_TAPCELL_ROW_95_1389 VGND VPWR sky130_fd_sc_hd__tapvpwrvgnd_1
XFILLER_0_436 VGND VGND VPWR VPWR sky130_fd_sc_hd__fill_2
XFILLER_114_180 VGND VGND VPWR VPWR sky130_fd_sc_hd__decap_3
XFILLER_88_521 VGND VGND VPWR VPWR sky130_fd_sc_hd__decap_3
XFILLER_88_543 VGND VGND VPWR VPWR sky130_fd_sc_hd__decap_3
X_6369_ _6532_/A VGND VGND VPWR VPWR _6369_/Y sky130_fd_sc_hd__inv_2
XFILLER_0_458 VGND VGND VPWR VPWR sky130_fd_sc_hd__decap_3
XFILLER_102_342 VGND VGND VPWR VPWR sky130_fd_sc_hd__fill_2
XFILLER_102_353 VGND VGND VPWR VPWR sky130_fd_sc_hd__decap_3
XFILLER_29_33 VGND VGND VPWR VPWR sky130_fd_sc_hd__fill_2
XFILLER_29_55 VGND VGND VPWR VPWR sky130_fd_sc_hd__fill_1
XFILLER_29_66 VGND VGND VPWR VPWR sky130_fd_sc_hd__fill_1
XFILLER_88_587 VGND VGND VPWR VPWR sky130_fd_sc_hd__fill_1
XFILLER_28_131 VGND VGND VPWR VPWR sky130_fd_sc_hd__decap_3
XFILLER_29_99 VGND VGND VPWR VPWR sky130_fd_sc_hd__decap_3
XTAP_TAPCELL_ROW_59_958 VGND VPWR sky130_fd_sc_hd__tapvpwrvgnd_1
XFILLER_16_304 VGND VGND VPWR VPWR sky130_fd_sc_hd__decap_3
XFILLER_16_315 VGND VGND VPWR VPWR sky130_fd_sc_hd__decap_3
XFILLER_56_473 VGND VGND VPWR VPWR sky130_fd_sc_hd__decap_3
XTAP_TAPCELL_ROW_3_285 VGND VPWR sky130_fd_sc_hd__tapvpwrvgnd_1
XFILLER_16_348 VGND VGND VPWR VPWR sky130_fd_sc_hd__fill_1
XFILLER_28_197 VGND VGND VPWR VPWR sky130_fd_sc_hd__decap_3
XFILLER_44_679 VGND VGND VPWR VPWR sky130_fd_sc_hd__decap_3
XFILLER_71_476 VGND VGND VPWR VPWR sky130_fd_sc_hd__fill_1
XFILLER_24_370 VGND VGND VPWR VPWR sky130_fd_sc_hd__decap_3
XFILLER_52_690 VGND VGND VPWR VPWR sky130_fd_sc_hd__fill_2
XFILLER_101_71 VGND VGND VPWR VPWR sky130_fd_sc_hd__decap_3
XTAP_TAPCELL_ROW_104_1496 VGND VPWR sky130_fd_sc_hd__tapvpwrvgnd_1
XFILLER_12_587 VGND VGND VPWR VPWR sky130_fd_sc_hd__fill_1
XFILLER_61_97 VGND VGND VPWR VPWR sky130_fd_sc_hd__decap_3
XFILLER_6_15 VGND VGND VPWR VPWR sky130_fd_sc_hd__decap_3
XFILLER_8_569 VGND VGND VPWR VPWR sky130_fd_sc_hd__fill_1
XANTENNA_8 _5648_/A VGND VGND VPWR VPWR sky130_fd_sc_hd__diode_2
XFILLER_6_59 VGND VGND VPWR VPWR sky130_fd_sc_hd__decap_3
XFILLER_112_106 VGND VGND VPWR VPWR sky130_fd_sc_hd__decap_3
XFILLER_113_629 VGND VGND VPWR VPWR sky130_fd_sc_hd__decap_3
XFILLER_106_681 VGND VGND VPWR VPWR sky130_fd_sc_hd__decap_3
XFILLER_112_139 VGND VGND VPWR VPWR sky130_fd_sc_hd__fill_1
XFILLER_3_285 VGND VGND VPWR VPWR sky130_fd_sc_hd__fill_1
XTAP_TAPCELL_ROW_72_1120 VGND VPWR sky130_fd_sc_hd__tapvpwrvgnd_1
XFILLER_39_407 VGND VGND VPWR VPWR sky130_fd_sc_hd__fill_1
XFILLER_79_554 VGND VGND VPWR VPWR sky130_fd_sc_hd__decap_3
XFILLER_79_576 VGND VGND VPWR VPWR sky130_fd_sc_hd__fill_2
XFILLER_94_513 VGND VGND VPWR VPWR sky130_fd_sc_hd__fill_2
XFILLER_66_237 VGND VGND VPWR VPWR sky130_fd_sc_hd__decap_3
XFILLER_66_259 VGND VGND VPWR VPWR sky130_fd_sc_hd__decap_3
XFILLER_86_94 VGND VGND VPWR VPWR sky130_fd_sc_hd__decap_3
XFILLER_19_142 VGND VGND VPWR VPWR sky130_fd_sc_hd__decap_3
XFILLER_19_197 VGND VGND VPWR VPWR sky130_fd_sc_hd__decap_3
XFILLER_34_112 VGND VGND VPWR VPWR sky130_fd_sc_hd__fill_1
XFILLER_35_635 VGND VGND VPWR VPWR sky130_fd_sc_hd__decap_3
XFILLER_47_495 VGND VGND VPWR VPWR sky130_fd_sc_hd__decap_3
XFILLER_62_421 VGND VGND VPWR VPWR sky130_fd_sc_hd__decap_3
XFILLER_62_432 VGND VGND VPWR VPWR sky130_fd_sc_hd__decap_3
XFILLER_34_167 VGND VGND VPWR VPWR sky130_fd_sc_hd__decap_3
XFILLER_35_679 VGND VGND VPWR VPWR sky130_fd_sc_hd__decap_3
XFILLER_22_318 VGND VGND VPWR VPWR sky130_fd_sc_hd__decap_3
XFILLER_50_627 VGND VGND VPWR VPWR sky130_fd_sc_hd__decap_3
XFILLER_30_362 VGND VGND VPWR VPWR sky130_fd_sc_hd__fill_2
X_5671_ _5671_/A _5671_/B VGND VGND VPWR VPWR _6983_/D sky130_fd_sc_hd__and2_2
X_4622_ _5072_/B _4621_/X _5071_/B VGND VGND VPWR VPWR _4622_/X sky130_fd_sc_hd__a21bo_2
X_7341_ _7403_/CLK _7341_/D _6621_/Y VGND VGND VPWR VPWR _7341_/Q sky130_fd_sc_hd__dfrtp_2
X_7272_ _7368_/CLK _7272_/D _6552_/Y VGND VGND VPWR VPWR _7272_/Q sky130_fd_sc_hd__dfrtp_2
X_4484_ _4484_/A0 _7305_/Q _4488_/S VGND VGND VPWR VPWR _7337_/D sky130_fd_sc_hd__mux2_2
X_3504_ _3501_/X _3502_/X _3630_/A VGND VGND VPWR VPWR _3505_/B sky130_fd_sc_hd__a21oi_2
XFILLER_116_489 VGND VGND VPWR VPWR sky130_fd_sc_hd__decap_3
XFILLER_103_128 VGND VGND VPWR VPWR sky130_fd_sc_hd__decap_3
XFILLER_103_139 VGND VGND VPWR VPWR sky130_fd_sc_hd__decap_3
XFILLER_106_27 VGND VGND VPWR VPWR sky130_fd_sc_hd__fill_1
XFILLER_106_38 VGND VGND VPWR VPWR sky130_fd_sc_hd__decap_3
XFILLER_112_640 VGND VGND VPWR VPWR sky130_fd_sc_hd__decap_3
XFILLER_112_651 VGND VGND VPWR VPWR sky130_fd_sc_hd__decap_3
X_3366_ _3376_/A _3376_/B _3399_/B _5118_/A VGND VGND VPWR VPWR _3366_/X sky130_fd_sc_hd__o211a_2
XFILLER_111_161 VGND VGND VPWR VPWR sky130_fd_sc_hd__decap_3
XFILLER_111_172 VGND VGND VPWR VPWR sky130_fd_sc_hd__decap_3
XFILLER_112_684 VGND VGND VPWR VPWR sky130_fd_sc_hd__decap_3
XFILLER_57_204 VGND VGND VPWR VPWR sky130_fd_sc_hd__decap_3
XFILLER_97_384 VGND VGND VPWR VPWR sky130_fd_sc_hd__decap_3
Xhold1203 _7160_/Q VGND VGND VPWR VPWR _5342_/A0 sky130_fd_sc_hd__dlygate4sd3_1
Xhold1214 _7305_/Q VGND VGND VPWR VPWR _4550_/A sky130_fd_sc_hd__dlygate4sd3_1
Xhold1225 _7228_/Q VGND VGND VPWR VPWR _5200_/A sky130_fd_sc_hd__dlygate4sd3_1
X_5105_ _4467_/B _3874_/X _5104_/Y _5666_/A VGND VGND VPWR VPWR _5105_/X sky130_fd_sc_hd__a31o_2
XFILLER_57_248 VGND VGND VPWR VPWR sky130_fd_sc_hd__decap_3
X_5036_ _5036_/A _4674_/X VGND VGND VPWR VPWR _5038_/A sky130_fd_sc_hd__or2b_2
XTAP_TAPCELL_ROW_56_928 VGND VPWR sky130_fd_sc_hd__tapvpwrvgnd_1
XTAP_TAPCELL_ROW_0_244 VGND VPWR sky130_fd_sc_hd__tapvpwrvgnd_1
X_6987_ _7398_/CLK _6987_/D _6267_/Y VGND VGND VPWR VPWR _6987_/Q sky130_fd_sc_hd__dfrtp_2
XTAP_TAPCELL_ROW_0_255 VGND VPWR sky130_fd_sc_hd__tapvpwrvgnd_1
XFILLER_13_329 VGND VGND VPWR VPWR sky130_fd_sc_hd__fill_1
XFILLER_15_24 VGND VGND VPWR VPWR sky130_fd_sc_hd__decap_3
XFILLER_15_57 VGND VGND VPWR VPWR sky130_fd_sc_hd__decap_3
XFILLER_41_627 VGND VGND VPWR VPWR sky130_fd_sc_hd__fill_1
XTAP_TAPCELL_ROW_36_685 VGND VPWR sky130_fd_sc_hd__tapvpwrvgnd_1
XFILLER_80_295 VGND VGND VPWR VPWR sky130_fd_sc_hd__decap_3
XFILLER_31_12 VGND VGND VPWR VPWR sky130_fd_sc_hd__decap_3
XTAP_TAPCELL_ROW_97_1418 VGND VPWR sky130_fd_sc_hd__tapvpwrvgnd_1
XFILLER_31_78 VGND VGND VPWR VPWR sky130_fd_sc_hd__decap_3
XTAP_TAPCELL_ROW_8_344 VGND VPWR sky130_fd_sc_hd__tapvpwrvgnd_1
XFILLER_0_222 VGND VGND VPWR VPWR sky130_fd_sc_hd__fill_2
XFILLER_103_662 VGND VGND VPWR VPWR sky130_fd_sc_hd__decap_3
XFILLER_103_673 VGND VGND VPWR VPWR sky130_fd_sc_hd__decap_3
XFILLER_76_513 VGND VGND VPWR VPWR sky130_fd_sc_hd__fill_2
XFILLER_88_395 VGND VGND VPWR VPWR sky130_fd_sc_hd__decap_3
XFILLER_17_613 VGND VGND VPWR VPWR sky130_fd_sc_hd__decap_3
XFILLER_56_42 VGND VGND VPWR VPWR sky130_fd_sc_hd__decap_3
XFILLER_16_101 VGND VGND VPWR VPWR sky130_fd_sc_hd__decap_3
XFILLER_17_624 VGND VGND VPWR VPWR sky130_fd_sc_hd__decap_3
XFILLER_17_646 VGND VGND VPWR VPWR sky130_fd_sc_hd__decap_3
XFILLER_44_421 VGND VGND VPWR VPWR sky130_fd_sc_hd__fill_1
XTAP_TAPCELL_ROW_106_1525 VGND VPWR sky130_fd_sc_hd__tapvpwrvgnd_1
XFILLER_17_668 VGND VGND VPWR VPWR sky130_fd_sc_hd__decap_3
XPHY_EDGE_ROW_113_Right_113 VGND VGND VPWR VPWR sky130_fd_sc_hd__decap_3
XFILLER_72_52 VGND VGND VPWR VPWR sky130_fd_sc_hd__decap_3
XFILLER_71_295 VGND VGND VPWR VPWR sky130_fd_sc_hd__decap_3
XFILLER_72_85 VGND VGND VPWR VPWR sky130_fd_sc_hd__decap_3
XFILLER_12_340 VGND VGND VPWR VPWR sky130_fd_sc_hd__decap_3
XFILLER_82_9 VGND VGND VPWR VPWR sky130_fd_sc_hd__decap_3
XFILLER_12_395 VGND VGND VPWR VPWR sky130_fd_sc_hd__decap_3
XFILLER_40_682 VGND VGND VPWR VPWR sky130_fd_sc_hd__decap_3
XFILLER_4_561 VGND VGND VPWR VPWR sky130_fd_sc_hd__decap_3
XFILLER_113_415 VGND VGND VPWR VPWR sky130_fd_sc_hd__decap_3
XFILLER_99_638 VGND VGND VPWR VPWR sky130_fd_sc_hd__decap_3
XFILLER_79_340 VGND VGND VPWR VPWR sky130_fd_sc_hd__decap_3
XFILLER_39_215 VGND VGND VPWR VPWR sky130_fd_sc_hd__decap_3
XFILLER_79_373 VGND VGND VPWR VPWR sky130_fd_sc_hd__decap_3
XFILLER_11_3 VGND VGND VPWR VPWR sky130_fd_sc_hd__decap_3
XFILLER_54_218 VGND VGND VPWR VPWR sky130_fd_sc_hd__decap_3
XFILLER_94_365 VGND VGND VPWR VPWR sky130_fd_sc_hd__decap_3
XFILLER_75_590 VGND VGND VPWR VPWR sky130_fd_sc_hd__decap_3
X_6910_ _6971_/CLK _6910_/D VGND VGND VPWR VPWR _6910_/Q sky130_fd_sc_hd__dfxtp_2
X_6841_ _6972_/CLK _6841_/D VGND VGND VPWR VPWR _6841_/Q sky130_fd_sc_hd__dfxtp_2
XFILLER_22_104 VGND VGND VPWR VPWR sky130_fd_sc_hd__decap_3
XFILLER_62_262 VGND VGND VPWR VPWR sky130_fd_sc_hd__decap_3
XTAP_TAPCELL_ROW_81_1219 VGND VPWR sky130_fd_sc_hd__tapvpwrvgnd_1
X_6772_ _6965_/CLK _6772_/D VGND VGND VPWR VPWR _6772_/Q sky130_fd_sc_hd__dfxtp_2
XTAP_TAPCELL_ROW_33_644 VGND VPWR sky130_fd_sc_hd__tapvpwrvgnd_1
X_5723_ _7367_/Q hold956/X _5737_/S VGND VGND VPWR VPWR _6711_/D sky130_fd_sc_hd__mux2_2
XTAP_TAPCELL_ROW_61_986 VGND VPWR sky130_fd_sc_hd__tapvpwrvgnd_1
X_5654_ _5665_/A VGND VGND VPWR VPWR _5654_/Y sky130_fd_sc_hd__inv_2
XFILLER_108_209 VGND VGND VPWR VPWR sky130_fd_sc_hd__decap_3
XFILLER_30_192 VGND VGND VPWR VPWR sky130_fd_sc_hd__decap_3
XFILLER_116_231 VGND VGND VPWR VPWR sky130_fd_sc_hd__decap_3
X_7324_ _7390_/CLK _7324_/D _6604_/Y VGND VGND VPWR VPWR _7324_/Q sky130_fd_sc_hd__dfrtp_2
X_5585_ hold948/X _5587_/B _5106_/X VGND VGND VPWR VPWR _7036_/D sky130_fd_sc_hd__a21o_2
XFILLER_116_253 VGND VGND VPWR VPWR sky130_fd_sc_hd__decap_3
X_4536_ hold939/X _3398_/Y _3488_/X VGND VGND VPWR VPWR _7311_/D sky130_fd_sc_hd__a21o_2
XFILLER_89_126 VGND VGND VPWR VPWR sky130_fd_sc_hd__decap_3
X_7255_ clkload7/A _7255_/D _6535_/Y VGND VGND VPWR VPWR _7255_/Q sky130_fd_sc_hd__dfrtp_2
X_4467_ _4467_/A _4467_/B VGND VGND VPWR VPWR _5015_/A sky130_fd_sc_hd__nor2_2
XTAP_TAPCELL_ROW_92_1359 VGND VPWR sky130_fd_sc_hd__tapvpwrvgnd_1
XFILLER_104_459 VGND VGND VPWR VPWR sky130_fd_sc_hd__decap_3
X_7186_ _7384_/CLK _7186_/D _6466_/Y VGND VGND VPWR VPWR _7186_/Q sky130_fd_sc_hd__dfrtp_2
X_4398_ _7338_/Q _3958_/S _4482_/S _7306_/Q VGND VGND VPWR VPWR _4398_/X sky130_fd_sc_hd__a22o_2
X_3418_ _7283_/Q _3415_/X _3417_/X _7091_/Q VGND VGND VPWR VPWR _3418_/X sky130_fd_sc_hd__a22o_2
XFILLER_98_660 VGND VGND VPWR VPWR sky130_fd_sc_hd__decap_3
XFILLER_112_470 VGND VGND VPWR VPWR sky130_fd_sc_hd__fill_1
Xhold1000 _7381_/Q VGND VGND VPWR VPWR _3901_/A1 sky130_fd_sc_hd__dlygate4sd3_1
X_3349_ _5129_/A _5294_/A VGND VGND VPWR VPWR _3350_/B sky130_fd_sc_hd__nand2_2
XTAP_TAPCELL_ROW_5_314 VGND VPWR sky130_fd_sc_hd__tapvpwrvgnd_1
XFILLER_100_632 VGND VGND VPWR VPWR sky130_fd_sc_hd__decap_3
XFILLER_100_654 VGND VGND VPWR VPWR sky130_fd_sc_hd__decap_3
XFILLER_112_492 VGND VGND VPWR VPWR sky130_fd_sc_hd__decap_3
Xhold1011 _7190_/Q VGND VGND VPWR VPWR _5280_/A0 sky130_fd_sc_hd__dlygate4sd3_1
Xhold1022 _7187_/Q VGND VGND VPWR VPWR _5284_/A0 sky130_fd_sc_hd__dlygate4sd3_1
Xhold1033 _7183_/Q VGND VGND VPWR VPWR _5292_/A0 sky130_fd_sc_hd__dlygate4sd3_1
XFILLER_100_687 VGND VGND VPWR VPWR sky130_fd_sc_hd__decap_3
XFILLER_85_376 VGND VGND VPWR VPWR sky130_fd_sc_hd__fill_2
XFILLER_93_18 VGND VGND VPWR VPWR sky130_fd_sc_hd__fill_1
Xhold1044 _7240_/Q VGND VGND VPWR VPWR _5175_/A sky130_fd_sc_hd__dlygate4sd3_1
Xhold1055 _7196_/Q VGND VGND VPWR VPWR _5268_/A0 sky130_fd_sc_hd__dlygate4sd3_1
Xhold1066 _7224_/Q VGND VGND VPWR VPWR _5209_/A sky130_fd_sc_hd__dlygate4sd3_1
XFILLER_26_12 VGND VGND VPWR VPWR sky130_fd_sc_hd__decap_3
XFILLER_26_421 VGND VGND VPWR VPWR sky130_fd_sc_hd__decap_3
XFILLER_38_281 VGND VGND VPWR VPWR sky130_fd_sc_hd__decap_3
Xhold1077 _7270_/Q VGND VGND VPWR VPWR _4865_/A0 sky130_fd_sc_hd__dlygate4sd3_1
Xhold1088 _7321_/Q VGND VGND VPWR VPWR _4517_/A0 sky130_fd_sc_hd__dlygate4sd3_1
Xhold1099 _7340_/Q VGND VGND VPWR VPWR _4478_/A0 sky130_fd_sc_hd__dlygate4sd3_1
X_5019_ _4243_/Y _5032_/B _4989_/X _5018_/Y VGND VGND VPWR VPWR _5020_/B sky130_fd_sc_hd__a22o_2
XFILLER_26_45 VGND VGND VPWR VPWR sky130_fd_sc_hd__decap_3
XFILLER_53_240 VGND VGND VPWR VPWR sky130_fd_sc_hd__decap_3
XFILLER_13_104 VGND VGND VPWR VPWR sky130_fd_sc_hd__decap_3
XFILLER_14_638 VGND VGND VPWR VPWR sky130_fd_sc_hd__decap_3
XFILLER_26_498 VGND VGND VPWR VPWR sky130_fd_sc_hd__decap_3
XFILLER_41_424 VGND VGND VPWR VPWR sky130_fd_sc_hd__decap_3
XFILLER_53_273 VGND VGND VPWR VPWR sky130_fd_sc_hd__decap_3
XFILLER_53_284 VGND VGND VPWR VPWR sky130_fd_sc_hd__decap_3
XFILLER_41_446 VGND VGND VPWR VPWR sky130_fd_sc_hd__fill_2
XTAP_TAPCELL_ROW_101_1466 VGND VPWR sky130_fd_sc_hd__tapvpwrvgnd_1
XFILLER_9_119 VGND VGND VPWR VPWR sky130_fd_sc_hd__decap_3
XFILLER_9_108 VGND VGND VPWR VPWR sky130_fd_sc_hd__decap_3
XFILLER_21_181 VGND VGND VPWR VPWR sky130_fd_sc_hd__decap_3
XFILLER_21_192 VGND VGND VPWR VPWR sky130_fd_sc_hd__fill_1
XFILLER_42_88 VGND VGND VPWR VPWR sky130_fd_sc_hd__decap_3
XFILLER_5_325 VGND VGND VPWR VPWR sky130_fd_sc_hd__decap_3
XFILLER_107_231 VGND VGND VPWR VPWR sky130_fd_sc_hd__fill_2
XFILLER_1_531 VGND VGND VPWR VPWR sky130_fd_sc_hd__decap_3
XFILLER_3_27 VGND VGND VPWR VPWR sky130_fd_sc_hd__decap_3
XFILLER_103_470 VGND VGND VPWR VPWR sky130_fd_sc_hd__decap_3
XFILLER_107_81 VGND VGND VPWR VPWR sky130_fd_sc_hd__decap_3
XFILLER_1_564 VGND VGND VPWR VPWR sky130_fd_sc_hd__decap_3
XFILLER_67_30 VGND VGND VPWR VPWR sky130_fd_sc_hd__decap_3
XFILLER_89_671 VGND VGND VPWR VPWR sky130_fd_sc_hd__fill_1
XFILLER_89_682 VGND VGND VPWR VPWR sky130_fd_sc_hd__decap_3
XFILLER_95_107 VGND VGND VPWR VPWR sky130_fd_sc_hd__decap_3
XTAP_TAPCELL_ROW_112_1595 VGND VPWR sky130_fd_sc_hd__tapvpwrvgnd_1
XFILLER_103_492 VGND VGND VPWR VPWR sky130_fd_sc_hd__decap_3
XFILLER_1_597 VGND VGND VPWR VPWR sky130_fd_sc_hd__decap_3
XFILLER_76_321 VGND VGND VPWR VPWR sky130_fd_sc_hd__decap_3
XFILLER_88_181 VGND VGND VPWR VPWR sky130_fd_sc_hd__decap_3
XFILLER_67_96 VGND VGND VPWR VPWR sky130_fd_sc_hd__decap_3
XFILLER_91_302 VGND VGND VPWR VPWR sky130_fd_sc_hd__decap_3
XFILLER_17_410 VGND VGND VPWR VPWR sky130_fd_sc_hd__fill_1
XFILLER_17_421 VGND VGND VPWR VPWR sky130_fd_sc_hd__decap_3
XFILLER_29_270 VGND VGND VPWR VPWR sky130_fd_sc_hd__decap_3
XFILLER_29_281 VGND VGND VPWR VPWR sky130_fd_sc_hd__fill_1
XFILLER_36_218 VGND VGND VPWR VPWR sky130_fd_sc_hd__decap_3
XFILLER_29_292 VGND VGND VPWR VPWR sky130_fd_sc_hd__decap_3
XFILLER_91_368 VGND VGND VPWR VPWR sky130_fd_sc_hd__decap_3
XTAP_TAPCELL_ROW_67_1052 VGND VPWR sky130_fd_sc_hd__tapvpwrvgnd_1
XFILLER_32_413 VGND VGND VPWR VPWR sky130_fd_sc_hd__decap_3
XFILLER_83_84 VGND VGND VPWR VPWR sky130_fd_sc_hd__decap_3
XFILLER_83_95 VGND VGND VPWR VPWR sky130_fd_sc_hd__decap_3
XFILLER_32_435 VGND VGND VPWR VPWR sky130_fd_sc_hd__decap_3
XFILLER_20_619 VGND VGND VPWR VPWR sky130_fd_sc_hd__fill_1
XFILLER_13_682 VGND VGND VPWR VPWR sky130_fd_sc_hd__fill_2
XFILLER_40_490 VGND VGND VPWR VPWR sky130_fd_sc_hd__decap_3
XFILLER_80_6 VGND VGND VPWR VPWR sky130_fd_sc_hd__decap_3
XFILLER_8_130 VGND VGND VPWR VPWR sky130_fd_sc_hd__decap_3
XTAP_TAPCELL_ROW_30_614 VGND VPWR sky130_fd_sc_hd__tapvpwrvgnd_1
XFILLER_12_192 VGND VGND VPWR VPWR sky130_fd_sc_hd__decap_3
XFILLER_8_152 VGND VGND VPWR VPWR sky130_fd_sc_hd__decap_3
XFILLER_59_3 VGND VGND VPWR VPWR sky130_fd_sc_hd__decap_3
XTAP_TAPCELL_ROW_10_371 VGND VPWR sky130_fd_sc_hd__tapvpwrvgnd_1
XFILLER_99_402 VGND VGND VPWR VPWR sky130_fd_sc_hd__decap_3
XFILLER_113_223 VGND VGND VPWR VPWR sky130_fd_sc_hd__fill_1
X_4321_ _7098_/Q _4351_/A2 _4351_/B1 _7130_/Q VGND VGND VPWR VPWR _4321_/X sky130_fd_sc_hd__a22o_2
XTAP_TAPCELL_ROW_78_1192 VGND VPWR sky130_fd_sc_hd__tapvpwrvgnd_1
XFILLER_113_234 VGND VGND VPWR VPWR sky130_fd_sc_hd__decap_3
XFILLER_4_391 VGND VGND VPWR VPWR sky130_fd_sc_hd__decap_3
X_7040_ _7387_/CLK _7040_/D _6320_/Y VGND VGND VPWR VPWR _7040_/Q sky130_fd_sc_hd__dfrtp_2
X_4252_ _7197_/Q _3968_/S _4272_/B _7357_/Q VGND VGND VPWR VPWR _4252_/X sky130_fd_sc_hd__a22o_2
XFILLER_101_407 VGND VGND VPWR VPWR sky130_fd_sc_hd__decap_3
XFILLER_101_418 VGND VGND VPWR VPWR sky130_fd_sc_hd__decap_3
XFILLER_101_429 VGND VGND VPWR VPWR sky130_fd_sc_hd__decap_3
XFILLER_113_267 VGND VGND VPWR VPWR sky130_fd_sc_hd__decap_3
XFILLER_95_641 VGND VGND VPWR VPWR sky130_fd_sc_hd__decap_3
X_4183_ _7360_/Q _4272_/B _4352_/B1 _7168_/Q _4182_/X VGND VGND VPWR VPWR _4183_/X
+ sky130_fd_sc_hd__a221o_2
XFILLER_27_207 VGND VGND VPWR VPWR sky130_fd_sc_hd__fill_2
XFILLER_55_505 VGND VGND VPWR VPWR sky130_fd_sc_hd__decap_3
XFILLER_95_685 VGND VGND VPWR VPWR sky130_fd_sc_hd__decap_3
XTAP_TAPCELL_ROW_38_703 VGND VPWR sky130_fd_sc_hd__tapvpwrvgnd_1
XFILLER_27_218 VGND VGND VPWR VPWR sky130_fd_sc_hd__decap_3
XFILLER_35_240 VGND VGND VPWR VPWR sky130_fd_sc_hd__decap_3
XFILLER_35_273 VGND VGND VPWR VPWR sky130_fd_sc_hd__fill_1
XFILLER_82_379 VGND VGND VPWR VPWR sky130_fd_sc_hd__decap_3
XFILLER_50_210 VGND VGND VPWR VPWR sky130_fd_sc_hd__decap_3
XFILLER_90_390 VGND VGND VPWR VPWR sky130_fd_sc_hd__fill_2
X_6824_ _6971_/CLK _6824_/D VGND VGND VPWR VPWR _6824_/Q sky130_fd_sc_hd__dfxtp_2
XTAP_TAPCELL_ROW_18_471 VGND VPWR sky130_fd_sc_hd__tapvpwrvgnd_1
XFILLER_50_265 VGND VGND VPWR VPWR sky130_fd_sc_hd__decap_3
X_6755_ _6975_/CLK _6755_/D VGND VGND VPWR VPWR _6755_/Q sky130_fd_sc_hd__dfxtp_2
XFILLER_10_118 VGND VGND VPWR VPWR sky130_fd_sc_hd__decap_3
XFILLER_50_298 VGND VGND VPWR VPWR sky130_fd_sc_hd__fill_1
X_5706_ _7359_/Q hold946/X _5706_/S VGND VGND VPWR VPWR _6703_/D sky130_fd_sc_hd__mux2_2
Xclkbuf_leaf_30_clk clkbuf_3_2__f_clk/X VGND VGND VPWR VPWR _6978_/CLK sky130_fd_sc_hd__clkbuf_16
X_6686_ _6686_/A VGND VGND VPWR VPWR _6686_/Y sky130_fd_sc_hd__inv_2
X_3898_ _6919_/Q _3926_/A2 _3926_/B1 _6783_/Q VGND VGND VPWR VPWR _3898_/X sky130_fd_sc_hd__a22o_2
XFILLER_12_47 VGND VGND VPWR VPWR sky130_fd_sc_hd__decap_3
XFILLER_88_18 VGND VGND VPWR VPWR sky130_fd_sc_hd__decap_3
X_5568_ hold951/X _4909_/A _4897_/X VGND VGND VPWR VPWR _7049_/D sky130_fd_sc_hd__a21o_2
X_7307_ _7368_/CLK _7307_/D _6587_/Y VGND VGND VPWR VPWR _7307_/Q sky130_fd_sc_hd__dfrtp_2
X_4519_ hold978/X _3398_/Y _4300_/X VGND VGND VPWR VPWR _7320_/D sky130_fd_sc_hd__a21o_2
X_7238_ _7334_/CLK _7238_/D _6518_/Y VGND VGND VPWR VPWR _7238_/Q sky130_fd_sc_hd__dfrtp_2
XFILLER_58_321 VGND VGND VPWR VPWR sky130_fd_sc_hd__decap_3
XFILLER_86_630 VGND VGND VPWR VPWR sky130_fd_sc_hd__decap_3
X_7169_ _7363_/CLK _7169_/D _6449_/Y VGND VGND VPWR VPWR _7169_/Q sky130_fd_sc_hd__dfrtp_2
XFILLER_100_451 VGND VGND VPWR VPWR sky130_fd_sc_hd__decap_3
XFILLER_37_33 VGND VGND VPWR VPWR sky130_fd_sc_hd__decap_3
XFILLER_58_365 VGND VGND VPWR VPWR sky130_fd_sc_hd__decap_3
XFILLER_73_302 VGND VGND VPWR VPWR sky130_fd_sc_hd__decap_3
XFILLER_85_140 VGND VGND VPWR VPWR sky130_fd_sc_hd__fill_1
XFILLER_85_151 VGND VGND VPWR VPWR sky130_fd_sc_hd__decap_3
XFILLER_86_663 VGND VGND VPWR VPWR sky130_fd_sc_hd__decap_3
XFILLER_100_495 VGND VGND VPWR VPWR sky130_fd_sc_hd__fill_1
XFILLER_18_229 VGND VGND VPWR VPWR sky130_fd_sc_hd__decap_3
XFILLER_37_66 VGND VGND VPWR VPWR sky130_fd_sc_hd__decap_3
XFILLER_73_324 VGND VGND VPWR VPWR sky130_fd_sc_hd__decap_3
XFILLER_85_184 VGND VGND VPWR VPWR sky130_fd_sc_hd__decap_3
XFILLER_37_99 VGND VGND VPWR VPWR sky130_fd_sc_hd__decap_3
XFILLER_73_346 VGND VGND VPWR VPWR sky130_fd_sc_hd__decap_3
XFILLER_73_379 VGND VGND VPWR VPWR sky130_fd_sc_hd__decap_3
XFILLER_53_21 VGND VGND VPWR VPWR sky130_fd_sc_hd__decap_3
XFILLER_41_265 VGND VGND VPWR VPWR sky130_fd_sc_hd__decap_3
XFILLER_41_287 VGND VGND VPWR VPWR sky130_fd_sc_hd__decap_3
Xclkbuf_leaf_21_clk clkbuf_3_6__f_clk/X VGND VGND VPWR VPWR _7390_/CLK sky130_fd_sc_hd__clkbuf_16
XFILLER_10_674 VGND VGND VPWR VPWR sky130_fd_sc_hd__decap_3
XFILLER_5_111 VGND VGND VPWR VPWR sky130_fd_sc_hd__fill_1
XFILLER_5_122 VGND VGND VPWR VPWR sky130_fd_sc_hd__decap_3
XFILLER_5_155 VGND VGND VPWR VPWR sky130_fd_sc_hd__decap_3
XFILLER_6_667 VGND VGND VPWR VPWR sky130_fd_sc_hd__decap_3
XFILLER_108_595 VGND VGND VPWR VPWR sky130_fd_sc_hd__decap_3
XTAP_TAPCELL_ROW_114_1624 VGND VPWR sky130_fd_sc_hd__tapvpwrvgnd_1
XFILLER_45_9 VGND VGND VPWR VPWR sky130_fd_sc_hd__decap_3
XFILLER_78_51 VGND VGND VPWR VPWR sky130_fd_sc_hd__decap_3
XFILLER_1_361 VGND VGND VPWR VPWR sky130_fd_sc_hd__decap_3
XFILLER_68_118 VGND VGND VPWR VPWR sky130_fd_sc_hd__decap_3
XFILLER_96_405 VGND VGND VPWR VPWR sky130_fd_sc_hd__decap_3
XFILLER_49_310 VGND VGND VPWR VPWR sky130_fd_sc_hd__decap_3
XFILLER_77_630 VGND VGND VPWR VPWR sky130_fd_sc_hd__decap_3
XFILLER_78_95 VGND VGND VPWR VPWR sky130_fd_sc_hd__fill_2
XFILLER_110_259 VGND VGND VPWR VPWR sky130_fd_sc_hd__decap_3
XFILLER_37_505 VGND VGND VPWR VPWR sky130_fd_sc_hd__fill_1
XFILLER_49_343 VGND VGND VPWR VPWR sky130_fd_sc_hd__decap_3
XFILLER_77_663 VGND VGND VPWR VPWR sky130_fd_sc_hd__decap_3
XFILLER_49_376 VGND VGND VPWR VPWR sky130_fd_sc_hd__fill_1
XFILLER_49_387 VGND VGND VPWR VPWR sky130_fd_sc_hd__fill_2
XFILLER_64_324 VGND VGND VPWR VPWR sky130_fd_sc_hd__fill_2
XFILLER_76_162 VGND VGND VPWR VPWR sky130_fd_sc_hd__decap_3
XFILLER_77_685 VGND VGND VPWR VPWR sky130_fd_sc_hd__decap_3
XFILLER_52_508 VGND VGND VPWR VPWR sky130_fd_sc_hd__decap_3
XFILLER_91_143 VGND VGND VPWR VPWR sky130_fd_sc_hd__decap_3
XFILLER_92_666 VGND VGND VPWR VPWR sky130_fd_sc_hd__decap_3
XFILLER_94_83 VGND VGND VPWR VPWR sky130_fd_sc_hd__fill_1
XFILLER_94_94 VGND VGND VPWR VPWR sky130_fd_sc_hd__decap_3
XFILLER_17_240 VGND VGND VPWR VPWR sky130_fd_sc_hd__decap_3
XFILLER_64_379 VGND VGND VPWR VPWR sky130_fd_sc_hd__decap_3
XFILLER_91_165 VGND VGND VPWR VPWR sky130_fd_sc_hd__decap_3
XFILLER_60_541 VGND VGND VPWR VPWR sky130_fd_sc_hd__fill_1
X_4870_ _4870_/A _4870_/B VGND VGND VPWR VPWR _4870_/Y sky130_fd_sc_hd__nor2_2
XFILLER_32_265 VGND VGND VPWR VPWR sky130_fd_sc_hd__decap_3
X_3821_ _3746_/C _3819_/X _3820_/X _3896_/B1 VGND VGND VPWR VPWR _5010_/C sky130_fd_sc_hd__o31a_2
XTAP_TAPCELL_ROW_15_430 VGND VPWR sky130_fd_sc_hd__tapvpwrvgnd_1
XFILLER_20_427 VGND VGND VPWR VPWR sky130_fd_sc_hd__decap_3
XFILLER_60_585 VGND VGND VPWR VPWR sky130_fd_sc_hd__decap_3
X_6540_ _6540_/A VGND VGND VPWR VPWR _6540_/Y sky130_fd_sc_hd__inv_2
XTAP_TAPCELL_ROW_43_772 VGND VPWR sky130_fd_sc_hd__tapvpwrvgnd_1
Xclkbuf_leaf_12_clk clkload1/A VGND VGND VPWR VPWR _7403_/CLK sky130_fd_sc_hd__clkbuf_16
X_3752_ _6799_/Q _3759_/A2 _3767_/A2 _6709_/Q _3751_/X VGND VGND VPWR VPWR _3752_/X
+ sky130_fd_sc_hd__a221o_2
X_6471_ _6634_/A VGND VGND VPWR VPWR _6471_/Y sky130_fd_sc_hd__inv_2
X_3683_ _3672_/X _3673_/X _3896_/B1 _3682_/Y VGND VGND VPWR VPWR _3683_/Y sky130_fd_sc_hd__o211ai_2
XFILLER_114_554 VGND VGND VPWR VPWR sky130_fd_sc_hd__decap_3
X_4304_ _7256_/Q _4341_/A2 _4303_/X VGND VGND VPWR VPWR _4364_/A sky130_fd_sc_hd__a21oi_2
XFILLER_99_254 VGND VGND VPWR VPWR sky130_fd_sc_hd__decap_3
XFILLER_114_587 VGND VGND VPWR VPWR sky130_fd_sc_hd__fill_1
XFILLER_87_405 VGND VGND VPWR VPWR sky130_fd_sc_hd__fill_1
X_5284_ _5284_/A0 _5135_/X _5292_/S VGND VGND VPWR VPWR _7187_/D sky130_fd_sc_hd__mux2_2
XFILLER_99_287 VGND VGND VPWR VPWR sky130_fd_sc_hd__decap_3
XFILLER_114_598 VGND VGND VPWR VPWR sky130_fd_sc_hd__decap_3
XFILLER_68_641 VGND VGND VPWR VPWR sky130_fd_sc_hd__decap_3
XFILLER_87_438 VGND VGND VPWR VPWR sky130_fd_sc_hd__decap_3
XFILLER_87_449 VGND VGND VPWR VPWR sky130_fd_sc_hd__decap_3
X_7023_ _7363_/CLK _7023_/D _6303_/Y VGND VGND VPWR VPWR _7023_/Q sky130_fd_sc_hd__dfrtp_2
X_4235_ _7227_/Q _3377_/X _4303_/B1 _7131_/Q VGND VGND VPWR VPWR _4235_/X sky130_fd_sc_hd__a22o_2
XFILLER_114_27 VGND VGND VPWR VPWR sky130_fd_sc_hd__fill_1
XFILLER_114_38 VGND VGND VPWR VPWR sky130_fd_sc_hd__decap_3
XFILLER_67_140 VGND VGND VPWR VPWR sky130_fd_sc_hd__decap_3
XFILLER_68_663 VGND VGND VPWR VPWR sky130_fd_sc_hd__decap_3
X_4166_ _7233_/Q _3318_/B _3954_/S _7201_/Q VGND VGND VPWR VPWR _4166_/X sky130_fd_sc_hd__a22o_2
XFILLER_55_324 VGND VGND VPWR VPWR sky130_fd_sc_hd__decap_3
XFILLER_67_162 VGND VGND VPWR VPWR sky130_fd_sc_hd__decap_3
XFILLER_55_357 VGND VGND VPWR VPWR sky130_fd_sc_hd__decap_3
XFILLER_67_195 VGND VGND VPWR VPWR sky130_fd_sc_hd__decap_3
XFILLER_83_644 VGND VGND VPWR VPWR sky130_fd_sc_hd__decap_3
XFILLER_70_305 VGND VGND VPWR VPWR sky130_fd_sc_hd__decap_3
XFILLER_70_349 VGND VGND VPWR VPWR sky130_fd_sc_hd__decap_3
XFILLER_23_243 VGND VGND VPWR VPWR sky130_fd_sc_hd__decap_3
Xplace390 _5666_/A VGND VGND VPWR VPWR _5640_/A sky130_fd_sc_hd__buf_2
X_6807_ _7005_/CLK _6807_/D VGND VGND VPWR VPWR _6807_/Q sky130_fd_sc_hd__dfxtp_2
XFILLER_23_24 VGND VGND VPWR VPWR sky130_fd_sc_hd__decap_3
XFILLER_23_287 VGND VGND VPWR VPWR sky130_fd_sc_hd__decap_3
XFILLER_51_596 VGND VGND VPWR VPWR sky130_fd_sc_hd__decap_3
XFILLER_23_57 VGND VGND VPWR VPWR sky130_fd_sc_hd__decap_3
X_6738_ _6978_/CLK _6738_/D VGND VGND VPWR VPWR _6738_/Q sky130_fd_sc_hd__dfxtp_2
XFILLER_109_337 VGND VGND VPWR VPWR sky130_fd_sc_hd__decap_3
X_6669_ _6672_/A VGND VGND VPWR VPWR _6669_/Y sky130_fd_sc_hd__inv_2
XTAP_TAPCELL_ROW_21_499 VGND VPWR sky130_fd_sc_hd__tapvpwrvgnd_1
XFILLER_2_103 VGND VGND VPWR VPWR sky130_fd_sc_hd__decap_3
XFILLER_3_637 VGND VGND VPWR VPWR sky130_fd_sc_hd__decap_3
XFILLER_105_543 VGND VGND VPWR VPWR sky130_fd_sc_hd__decap_3
XFILLER_2_136 VGND VGND VPWR VPWR sky130_fd_sc_hd__decap_3
XFILLER_2_147 VGND VGND VPWR VPWR sky130_fd_sc_hd__decap_3
XFILLER_105_576 VGND VGND VPWR VPWR sky130_fd_sc_hd__fill_2
XFILLER_78_416 VGND VGND VPWR VPWR sky130_fd_sc_hd__decap_3
XFILLER_78_427 VGND VGND VPWR VPWR sky130_fd_sc_hd__decap_3
XFILLER_105_598 VGND VGND VPWR VPWR sky130_fd_sc_hd__decap_3
XFILLER_48_21 VGND VGND VPWR VPWR sky130_fd_sc_hd__decap_3
XFILLER_59_641 VGND VGND VPWR VPWR sky130_fd_sc_hd__decap_3
XFILLER_86_460 VGND VGND VPWR VPWR sky130_fd_sc_hd__decap_3
XFILLER_0_17 VGND VGND VPWR VPWR sky130_fd_sc_hd__decap_3
XFILLER_100_270 VGND VGND VPWR VPWR sky130_fd_sc_hd__decap_3
XFILLER_46_324 VGND VGND VPWR VPWR sky130_fd_sc_hd__fill_1
XFILLER_58_162 VGND VGND VPWR VPWR sky130_fd_sc_hd__decap_3
XFILLER_59_685 VGND VGND VPWR VPWR sky130_fd_sc_hd__decap_3
XFILLER_104_71 VGND VGND VPWR VPWR sky130_fd_sc_hd__decap_3
XFILLER_46_335 VGND VGND VPWR VPWR sky130_fd_sc_hd__fill_2
XFILLER_74_666 VGND VGND VPWR VPWR sky130_fd_sc_hd__decap_3
XFILLER_61_316 VGND VGND VPWR VPWR sky130_fd_sc_hd__decap_3
XFILLER_73_176 VGND VGND VPWR VPWR sky130_fd_sc_hd__decap_3
XFILLER_14_221 VGND VGND VPWR VPWR sky130_fd_sc_hd__decap_3
XFILLER_27_582 VGND VGND VPWR VPWR sky130_fd_sc_hd__decap_3
XFILLER_61_349 VGND VGND VPWR VPWR sky130_fd_sc_hd__decap_3
XTAP_TAPCELL_ROW_64_1022 VGND VPWR sky130_fd_sc_hd__tapvpwrvgnd_1
XTAP_TAPCELL_ROW_29_599 VGND VPWR sky130_fd_sc_hd__tapvpwrvgnd_1
XFILLER_14_265 VGND VGND VPWR VPWR sky130_fd_sc_hd__decap_3
XFILLER_9_15 VGND VGND VPWR VPWR sky130_fd_sc_hd__decap_3
XTAP_TAPCELL_ROW_12_400 VGND VPWR sky130_fd_sc_hd__tapvpwrvgnd_1
XFILLER_9_48 VGND VGND VPWR VPWR sky130_fd_sc_hd__decap_3
XFILLER_80_74 VGND VGND VPWR VPWR sky130_fd_sc_hd__decap_3
XTAP_TAPCELL_ROW_40_731 VGND VPWR sky130_fd_sc_hd__tapvpwrvgnd_1
XFILLER_80_85 VGND VGND VPWR VPWR sky130_fd_sc_hd__decap_3
XFILLER_6_442 VGND VGND VPWR VPWR sky130_fd_sc_hd__decap_3
XFILLER_89_50 VGND VGND VPWR VPWR sky130_fd_sc_hd__decap_3
XFILLER_43_6 VGND VGND VPWR VPWR sky130_fd_sc_hd__decap_3
XTAP_TAPCELL_ROW_75_1151 VGND VPWR sky130_fd_sc_hd__tapvpwrvgnd_1
XFILLER_69_405 VGND VGND VPWR VPWR sky130_fd_sc_hd__fill_1
XFILLER_69_427 VGND VGND VPWR VPWR sky130_fd_sc_hd__decap_3
XFILLER_2_681 VGND VGND VPWR VPWR sky130_fd_sc_hd__decap_3
XFILLER_69_449 VGND VGND VPWR VPWR sky130_fd_sc_hd__decap_3
XFILLER_111_557 VGND VGND VPWR VPWR sky130_fd_sc_hd__decap_3
XFILLER_111_579 VGND VGND VPWR VPWR sky130_fd_sc_hd__decap_3
XFILLER_65_600 VGND VGND VPWR VPWR sky130_fd_sc_hd__decap_3
Xclkbuf_leaf_1_clk clkbuf_leaf_1_clk/A VGND VGND VPWR VPWR clkload8/A sky130_fd_sc_hd__clkbuf_16
X_4020_ _7086_/Q _4432_/A2 _4432_/B1 _4019_/X VGND VGND VPWR VPWR _4039_/A sky130_fd_sc_hd__o211ai_2
XFILLER_37_324 VGND VGND VPWR VPWR sky130_fd_sc_hd__fill_1
XFILLER_49_162 VGND VGND VPWR VPWR sky130_fd_sc_hd__decap_3
XFILLER_49_184 VGND VGND VPWR VPWR sky130_fd_sc_hd__decap_3
XFILLER_64_121 VGND VGND VPWR VPWR sky130_fd_sc_hd__decap_3
XFILLER_65_644 VGND VGND VPWR VPWR sky130_fd_sc_hd__decap_3
XFILLER_92_430 VGND VGND VPWR VPWR sky130_fd_sc_hd__decap_3
XTAP_TAPCELL_ROW_48_831 VGND VPWR sky130_fd_sc_hd__tapvpwrvgnd_1
XFILLER_25_508 VGND VGND VPWR VPWR sky130_fd_sc_hd__decap_3
XFILLER_65_688 VGND VGND VPWR VPWR sky130_fd_sc_hd__decap_3
XFILLER_80_603 VGND VGND VPWR VPWR sky130_fd_sc_hd__decap_3
XFILLER_52_327 VGND VGND VPWR VPWR sky130_fd_sc_hd__decap_3
XFILLER_80_636 VGND VGND VPWR VPWR sky130_fd_sc_hd__decap_3
XFILLER_80_669 VGND VGND VPWR VPWR sky130_fd_sc_hd__decap_3
X_4922_ _4937_/A _4937_/B _4203_/X VGND VGND VPWR VPWR _4922_/X sky130_fd_sc_hd__a21o_2
XTAP_TAPCELL_ROW_86_1280 VGND VPWR sky130_fd_sc_hd__tapvpwrvgnd_1
XFILLER_100_29 VGND VGND VPWR VPWR sky130_fd_sc_hd__decap_3
XFILLER_60_360 VGND VGND VPWR VPWR sky130_fd_sc_hd__fill_1
XFILLER_60_382 VGND VGND VPWR VPWR sky130_fd_sc_hd__decap_3
X_4784_ _4813_/A _4829_/B VGND VGND VPWR VPWR _4811_/B sky130_fd_sc_hd__nand2_2
X_3804_ _6826_/Q _3879_/A2 _3884_/B1 _6811_/Q _3803_/X VGND VGND VPWR VPWR _3804_/X
+ sky130_fd_sc_hd__a221o_2
XFILLER_20_268 VGND VGND VPWR VPWR sky130_fd_sc_hd__fill_2
X_6523_ _6523_/A VGND VGND VPWR VPWR _6523_/Y sky130_fd_sc_hd__inv_2
X_3735_ _3735_/A _3746_/B _3746_/C VGND VGND VPWR VPWR _3735_/X sky130_fd_sc_hd__and3_4
XFILLER_109_27 VGND VGND VPWR VPWR sky130_fd_sc_hd__decap_3
X_6454_ _6675_/A VGND VGND VPWR VPWR _6454_/Y sky130_fd_sc_hd__inv_2
XFILLER_106_307 VGND VGND VPWR VPWR sky130_fd_sc_hd__fill_1
X_6385_ _6385_/A VGND VGND VPWR VPWR _6385_/Y sky130_fd_sc_hd__inv_2
X_3597_ _4295_/B _3607_/B VGND VGND VPWR VPWR _3611_/B sky130_fd_sc_hd__nor2_2
XFILLER_0_629 VGND VGND VPWR VPWR sky130_fd_sc_hd__fill_1
XFILLER_114_351 VGND VGND VPWR VPWR sky130_fd_sc_hd__decap_3
X_5336_ _5336_/A0 _5040_/X _5358_/S VGND VGND VPWR VPWR _7163_/D sky130_fd_sc_hd__mux2_2
XFILLER_102_579 VGND VGND VPWR VPWR sky130_fd_sc_hd__fill_1
XFILLER_75_408 VGND VGND VPWR VPWR sky130_fd_sc_hd__decap_3
X_7006_ _7374_/CLK _7006_/D _6286_/Y VGND VGND VPWR VPWR _7006_/Q sky130_fd_sc_hd__dfrtp_2
X_4218_ _7100_/Q _4250_/A2 _4351_/B1 _7132_/Q VGND VGND VPWR VPWR _4218_/X sky130_fd_sc_hd__a22o_2
XFILLER_18_24 VGND VGND VPWR VPWR sky130_fd_sc_hd__decap_3
XFILLER_56_622 VGND VGND VPWR VPWR sky130_fd_sc_hd__decap_3
X_5198_ _5198_/A _5225_/B VGND VGND VPWR VPWR _7229_/D sky130_fd_sc_hd__and2_2
XFILLER_55_121 VGND VGND VPWR VPWR sky130_fd_sc_hd__decap_3
XFILLER_68_493 VGND VGND VPWR VPWR sky130_fd_sc_hd__fill_2
XFILLER_83_430 VGND VGND VPWR VPWR sky130_fd_sc_hd__decap_3
XFILLER_83_452 VGND VGND VPWR VPWR sky130_fd_sc_hd__decap_3
X_4149_ _4205_/A _4205_/B VGND VGND VPWR VPWR _4157_/A sky130_fd_sc_hd__nand2_2
XFILLER_43_305 VGND VGND VPWR VPWR sky130_fd_sc_hd__decap_3
XFILLER_56_677 VGND VGND VPWR VPWR sky130_fd_sc_hd__decap_3
XFILLER_83_474 VGND VGND VPWR VPWR sky130_fd_sc_hd__decap_3
XFILLER_34_12 VGND VGND VPWR VPWR sky130_fd_sc_hd__decap_3
XFILLER_43_349 VGND VGND VPWR VPWR sky130_fd_sc_hd__fill_2
XFILLER_55_198 VGND VGND VPWR VPWR sky130_fd_sc_hd__decap_3
XFILLER_70_124 VGND VGND VPWR VPWR sky130_fd_sc_hd__decap_3
XFILLER_71_647 VGND VGND VPWR VPWR sky130_fd_sc_hd__decap_3
XFILLER_70_168 VGND VGND VPWR VPWR sky130_fd_sc_hd__decap_3
XTAP_TAPCELL_ROW_26_569 VGND VPWR sky130_fd_sc_hd__tapvpwrvgnd_1
XTAP_TAPCELL_ROW_26_558 VGND VPWR sky130_fd_sc_hd__tapvpwrvgnd_1
XFILLER_34_67 VGND VGND VPWR VPWR sky130_fd_sc_hd__decap_3
XFILLER_51_382 VGND VGND VPWR VPWR sky130_fd_sc_hd__fill_1
XFILLER_11_246 VGND VGND VPWR VPWR sky130_fd_sc_hd__decap_3
XFILLER_11_279 VGND VGND VPWR VPWR sky130_fd_sc_hd__fill_1
XFILLER_7_228 VGND VGND VPWR VPWR sky130_fd_sc_hd__decap_3
Xclkload0 clkload0/A VGND VGND VPWR VPWR clkload0/X sky130_fd_sc_hd__clkbuf_16
XFILLER_109_134 VGND VGND VPWR VPWR sky130_fd_sc_hd__decap_3
XFILLER_50_55 VGND VGND VPWR VPWR sky130_fd_sc_hd__decap_3
XFILLER_109_167 VGND VGND VPWR VPWR sky130_fd_sc_hd__fill_1
XFILLER_109_178 VGND VGND VPWR VPWR sky130_fd_sc_hd__decap_3
XFILLER_50_88 VGND VGND VPWR VPWR sky130_fd_sc_hd__decap_3
XFILLER_3_423 VGND VGND VPWR VPWR sky130_fd_sc_hd__decap_3
XFILLER_105_351 VGND VGND VPWR VPWR sky130_fd_sc_hd__decap_3
XFILLER_105_362 VGND VGND VPWR VPWR sky130_fd_sc_hd__decap_3
XFILLER_3_467 VGND VGND VPWR VPWR sky130_fd_sc_hd__fill_1
XFILLER_59_42 VGND VGND VPWR VPWR sky130_fd_sc_hd__decap_3
XFILLER_59_75 VGND VGND VPWR VPWR sky130_fd_sc_hd__decap_3
XFILLER_78_268 VGND VGND VPWR VPWR sky130_fd_sc_hd__decap_3
XFILLER_115_81 VGND VGND VPWR VPWR sky130_fd_sc_hd__decap_3
XTAP_TAPCELL_ROW_70_1092 VGND VPWR sky130_fd_sc_hd__tapvpwrvgnd_1
XFILLER_46_132 VGND VGND VPWR VPWR sky130_fd_sc_hd__decap_3
XFILLER_47_644 VGND VGND VPWR VPWR sky130_fd_sc_hd__decap_3
XFILLER_46_165 VGND VGND VPWR VPWR sky130_fd_sc_hd__decap_3
XFILLER_47_688 VGND VGND VPWR VPWR sky130_fd_sc_hd__decap_3
XFILLER_62_625 VGND VGND VPWR VPWR sky130_fd_sc_hd__decap_3
XFILLER_74_474 VGND VGND VPWR VPWR sky130_fd_sc_hd__fill_2
XTAP_TAPCELL_ROW_109_1556 VGND VPWR sky130_fd_sc_hd__tapvpwrvgnd_1
XFILLER_61_113 VGND VGND VPWR VPWR sky130_fd_sc_hd__decap_3
XFILLER_62_669 VGND VGND VPWR VPWR sky130_fd_sc_hd__decap_3
XFILLER_30_522 VGND VGND VPWR VPWR sky130_fd_sc_hd__fill_2
XFILLER_42_382 VGND VGND VPWR VPWR sky130_fd_sc_hd__decap_3
XFILLER_91_84 VGND VGND VPWR VPWR sky130_fd_sc_hd__decap_3
X_3520_ _5118_/D _3354_/X _3519_/Y _3350_/B VGND VGND VPWR VPWR _3525_/B sky130_fd_sc_hd__o2bb2a_2
XFILLER_116_638 VGND VGND VPWR VPWR sky130_fd_sc_hd__decap_3
XFILLER_6_250 VGND VGND VPWR VPWR sky130_fd_sc_hd__fill_2
Xhold707 _6835_/Q VGND VGND VPWR VPWR _6835_/D sky130_fd_sc_hd__dlygate4sd3_1
Xhold718 _6859_/Q VGND VGND VPWR VPWR _6859_/D sky130_fd_sc_hd__dlygate4sd3_1
XFILLER_115_137 VGND VGND VPWR VPWR sky130_fd_sc_hd__decap_3
Xhold729 _6742_/Q VGND VGND VPWR VPWR _6742_/D sky130_fd_sc_hd__dlygate4sd3_1
XFILLER_97_511 VGND VGND VPWR VPWR sky130_fd_sc_hd__decap_3
X_5121_ _5139_/B1 _5117_/X _5118_/X _6984_/D _5666_/A VGND VGND VPWR VPWR _5121_/X
+ sky130_fd_sc_hd__a32o_2
XFILLER_111_343 VGND VGND VPWR VPWR sky130_fd_sc_hd__decap_3
XFILLER_69_246 VGND VGND VPWR VPWR sky130_fd_sc_hd__decap_3
XFILLER_111_376 VGND VGND VPWR VPWR sky130_fd_sc_hd__decap_3
XFILLER_84_216 VGND VGND VPWR VPWR sky130_fd_sc_hd__fill_1
XFILLER_97_588 VGND VGND VPWR VPWR sky130_fd_sc_hd__decap_3
X_5052_ _3548_/X _5049_/X _5051_/X _3618_/X VGND VGND VPWR VPWR _5052_/X sky130_fd_sc_hd__a2bb2o_2
XFILLER_1_60 VGND VGND VPWR VPWR sky130_fd_sc_hd__decap_3
XFILLER_38_666 VGND VGND VPWR VPWR sky130_fd_sc_hd__decap_3
XFILLER_65_452 VGND VGND VPWR VPWR sky130_fd_sc_hd__fill_2
XFILLER_1_93 VGND VGND VPWR VPWR sky130_fd_sc_hd__decap_3
XFILLER_25_349 VGND VGND VPWR VPWR sky130_fd_sc_hd__decap_3
XFILLER_37_198 VGND VGND VPWR VPWR sky130_fd_sc_hd__decap_3
XFILLER_52_113 VGND VGND VPWR VPWR sky130_fd_sc_hd__decap_3
XFILLER_53_647 VGND VGND VPWR VPWR sky130_fd_sc_hd__decap_3
XFILLER_80_411 VGND VGND VPWR VPWR sky130_fd_sc_hd__decap_3
XFILLER_80_433 VGND VGND VPWR VPWR sky130_fd_sc_hd__decap_3
XFILLER_80_455 VGND VGND VPWR VPWR sky130_fd_sc_hd__decap_3
XFILLER_80_466 VGND VGND VPWR VPWR sky130_fd_sc_hd__decap_3
XFILLER_80_477 VGND VGND VPWR VPWR sky130_fd_sc_hd__decap_3
XFILLER_61_691 VGND VGND VPWR VPWR sky130_fd_sc_hd__fill_1
X_4905_ _3526_/B _4888_/A _4903_/A _5101_/A VGND VGND VPWR VPWR _4905_/X sky130_fd_sc_hd__o2bb2a_2
XTAP_TAPCELL_ROW_23_528 VGND VPWR sky130_fd_sc_hd__tapvpwrvgnd_1
XFILLER_33_393 VGND VGND VPWR VPWR sky130_fd_sc_hd__decap_3
XFILLER_60_190 VGND VGND VPWR VPWR sky130_fd_sc_hd__decap_3
X_4836_ _7001_/D _4835_/X _4836_/S VGND VGND VPWR VPWR _4836_/X sky130_fd_sc_hd__mux2_2
XTAP_TAPCELL_ROW_51_859 VGND VPWR sky130_fd_sc_hd__tapvpwrvgnd_1
XFILLER_21_577 VGND VGND VPWR VPWR sky130_fd_sc_hd__fill_1
X_6506_ _6535_/A VGND VGND VPWR VPWR _6506_/Y sky130_fd_sc_hd__inv_2
X_4767_ _5057_/A _4452_/A _4453_/A _4852_/A _4766_/Y VGND VGND VPWR VPWR _4767_/X
+ sky130_fd_sc_hd__o221a_2
XFILLER_107_638 VGND VGND VPWR VPWR sky130_fd_sc_hd__decap_3
XFILLER_4_209 VGND VGND VPWR VPWR sky130_fd_sc_hd__fill_2
X_4698_ _6985_/Q _5120_/A VGND VGND VPWR VPWR _5098_/A sky130_fd_sc_hd__and2_2
XFILLER_106_126 VGND VGND VPWR VPWR sky130_fd_sc_hd__decap_3
XFILLER_20_58 VGND VGND VPWR VPWR sky130_fd_sc_hd__decap_3
X_6437_ _6570_/A VGND VGND VPWR VPWR _6437_/Y sky130_fd_sc_hd__inv_2
XFILLER_115_671 VGND VGND VPWR VPWR sky130_fd_sc_hd__fill_1
X_6368_ _6567_/A VGND VGND VPWR VPWR _6368_/Y sky130_fd_sc_hd__inv_2
XFILLER_0_415 VGND VGND VPWR VPWR sky130_fd_sc_hd__decap_3
XFILLER_102_321 VGND VGND VPWR VPWR sky130_fd_sc_hd__decap_3
XFILLER_115_682 VGND VGND VPWR VPWR sky130_fd_sc_hd__fill_2
XFILLER_88_533 VGND VGND VPWR VPWR sky130_fd_sc_hd__fill_1
XFILLER_96_29 VGND VGND VPWR VPWR sky130_fd_sc_hd__decap_3
X_5319_ _5319_/A0 _4913_/X _7412_/A VGND VGND VPWR VPWR _7171_/D sky130_fd_sc_hd__mux2_2
XFILLER_114_192 VGND VGND VPWR VPWR sky130_fd_sc_hd__decap_3
XFILLER_29_12 VGND VGND VPWR VPWR sky130_fd_sc_hd__decap_3
X_6299_ _6366_/A VGND VGND VPWR VPWR _6299_/Y sky130_fd_sc_hd__inv_2
XFILLER_102_376 VGND VGND VPWR VPWR sky130_fd_sc_hd__decap_3
XFILLER_29_78 VGND VGND VPWR VPWR sky130_fd_sc_hd__fill_2
XFILLER_48_419 VGND VGND VPWR VPWR sky130_fd_sc_hd__fill_1
XTAP_TAPCELL_ROW_59_959 VGND VPWR sky130_fd_sc_hd__tapvpwrvgnd_1
XFILLER_44_603 VGND VGND VPWR VPWR sky130_fd_sc_hd__decap_3
XFILLER_56_452 VGND VGND VPWR VPWR sky130_fd_sc_hd__decap_3
XTAP_TAPCELL_ROW_3_286 VGND VPWR sky130_fd_sc_hd__tapvpwrvgnd_1
XFILLER_43_113 VGND VGND VPWR VPWR sky130_fd_sc_hd__decap_3
XFILLER_45_33 VGND VGND VPWR VPWR sky130_fd_sc_hd__fill_2
XFILLER_43_157 VGND VGND VPWR VPWR sky130_fd_sc_hd__decap_3
XFILLER_45_77 VGND VGND VPWR VPWR sky130_fd_sc_hd__decap_3
XFILLER_101_50 VGND VGND VPWR VPWR sky130_fd_sc_hd__decap_3
XFILLER_24_360 VGND VGND VPWR VPWR sky130_fd_sc_hd__decap_3
XFILLER_101_83 VGND VGND VPWR VPWR sky130_fd_sc_hd__decap_3
XFILLER_12_522 VGND VGND VPWR VPWR sky130_fd_sc_hd__fill_1
XFILLER_24_382 VGND VGND VPWR VPWR sky130_fd_sc_hd__decap_3
XFILLER_61_21 VGND VGND VPWR VPWR sky130_fd_sc_hd__decap_3
XFILLER_8_504 VGND VGND VPWR VPWR sky130_fd_sc_hd__fill_2
XTAP_TAPCELL_ROW_104_1497 VGND VPWR sky130_fd_sc_hd__tapvpwrvgnd_1
XANTENNA_9 _3813_/Y VGND VGND VPWR VPWR sky130_fd_sc_hd__diode_2
XFILLER_6_27 VGND VGND VPWR VPWR sky130_fd_sc_hd__fill_1
XFILLER_6_38 VGND VGND VPWR VPWR sky130_fd_sc_hd__decap_3
XFILLER_106_660 VGND VGND VPWR VPWR sky130_fd_sc_hd__decap_3
XTAP_TAPCELL_ROW_72_1110 VGND VPWR sky130_fd_sc_hd__tapvpwrvgnd_1
XFILLER_98_319 VGND VGND VPWR VPWR sky130_fd_sc_hd__decap_3
XFILLER_10_80 VGND VGND VPWR VPWR sky130_fd_sc_hd__decap_3
XFILLER_10_91 VGND VGND VPWR VPWR sky130_fd_sc_hd__decap_3
XFILLER_112_118 VGND VGND VPWR VPWR sky130_fd_sc_hd__decap_3
XTAP_TAPCELL_ROW_72_1121 VGND VPWR sky130_fd_sc_hd__tapvpwrvgnd_1
XFILLER_105_181 VGND VGND VPWR VPWR sky130_fd_sc_hd__fill_1
XFILLER_86_40 VGND VGND VPWR VPWR sky130_fd_sc_hd__fill_2
XFILLER_66_216 VGND VGND VPWR VPWR sky130_fd_sc_hd__decap_3
XFILLER_79_599 VGND VGND VPWR VPWR sky130_fd_sc_hd__decap_3
XFILLER_86_73 VGND VGND VPWR VPWR sky130_fd_sc_hd__decap_3
XFILLER_94_536 VGND VGND VPWR VPWR sky130_fd_sc_hd__decap_3
XFILLER_19_110 VGND VGND VPWR VPWR sky130_fd_sc_hd__fill_2
XFILLER_94_569 VGND VGND VPWR VPWR sky130_fd_sc_hd__decap_3
XFILLER_47_452 VGND VGND VPWR VPWR sky130_fd_sc_hd__decap_3
XFILLER_62_411 VGND VGND VPWR VPWR sky130_fd_sc_hd__decap_3
XFILLER_74_271 VGND VGND VPWR VPWR sky130_fd_sc_hd__decap_3
XFILLER_74_282 VGND VGND VPWR VPWR sky130_fd_sc_hd__fill_2
XFILLER_50_606 VGND VGND VPWR VPWR sky130_fd_sc_hd__decap_3
XFILLER_62_444 VGND VGND VPWR VPWR sky130_fd_sc_hd__decap_3
XFILLER_34_179 VGND VGND VPWR VPWR sky130_fd_sc_hd__decap_3
XFILLER_50_639 VGND VGND VPWR VPWR sky130_fd_sc_hd__decap_3
XTAP_TAPCELL_ROW_83_1250 VGND VPWR sky130_fd_sc_hd__tapvpwrvgnd_1
XFILLER_15_393 VGND VGND VPWR VPWR sky130_fd_sc_hd__decap_3
XFILLER_30_330 VGND VGND VPWR VPWR sky130_fd_sc_hd__decap_3
X_5670_ _6983_/Q _5670_/B VGND VGND VPWR VPWR _5671_/B sky130_fd_sc_hd__nand2_2
XFILLER_89_3 VGND VGND VPWR VPWR sky130_fd_sc_hd__decap_3
X_4621_ _4315_/B _4343_/X _4315_/A VGND VGND VPWR VPWR _4621_/X sky130_fd_sc_hd__a21bo_2
XFILLER_30_374 VGND VGND VPWR VPWR sky130_fd_sc_hd__fill_2
XFILLER_30_385 VGND VGND VPWR VPWR sky130_fd_sc_hd__decap_3
XFILLER_30_396 VGND VGND VPWR VPWR sky130_fd_sc_hd__fill_1
XFILLER_116_402 VGND VGND VPWR VPWR sky130_fd_sc_hd__decap_3
X_7340_ _7372_/CLK _7340_/D _6620_/Y VGND VGND VPWR VPWR _7340_/Q sky130_fd_sc_hd__dfrtp_2
X_4552_ _4552_/A _4563_/B VGND VGND VPWR VPWR _7304_/D sky130_fd_sc_hd__and2_2
XFILLER_116_424 VGND VGND VPWR VPWR sky130_fd_sc_hd__decap_3
XFILLER_116_435 VGND VGND VPWR VPWR sky130_fd_sc_hd__decap_3
XFILLER_116_446 VGND VGND VPWR VPWR sky130_fd_sc_hd__fill_2
X_7271_ _7337_/CLK _7271_/D _6551_/Y VGND VGND VPWR VPWR _7271_/Q sky130_fd_sc_hd__dfrtp_2
X_3503_ _3545_/A _3545_/B VGND VGND VPWR VPWR _3630_/A sky130_fd_sc_hd__xor2_4
XFILLER_104_619 VGND VGND VPWR VPWR sky130_fd_sc_hd__decap_3
XFILLER_89_319 VGND VGND VPWR VPWR sky130_fd_sc_hd__decap_3
X_3434_ _7218_/Q _3377_/X _4303_/B1 _7122_/Q VGND VGND VPWR VPWR _3434_/X sky130_fd_sc_hd__a22o_2
XFILLER_103_107 VGND VGND VPWR VPWR sky130_fd_sc_hd__decap_3
XFILLER_112_663 VGND VGND VPWR VPWR sky130_fd_sc_hd__decap_3
X_3365_ _3365_/A VGND VGND VPWR VPWR _5118_/A sky130_fd_sc_hd__inv_2
XFILLER_111_140 VGND VGND VPWR VPWR sky130_fd_sc_hd__decap_3
Xhold1204 _7329_/Q VGND VGND VPWR VPWR _4501_/A0 sky130_fd_sc_hd__dlygate4sd3_1
Xhold1215 _7286_/Q VGND VGND VPWR VPWR _4589_/A sky130_fd_sc_hd__dlygate4sd3_1
X_5104_ _5104_/A _5660_/C VGND VGND VPWR VPWR _5104_/Y sky130_fd_sc_hd__nand2_2
XFILLER_111_184 VGND VGND VPWR VPWR sky130_fd_sc_hd__decap_3
XFILLER_38_430 VGND VGND VPWR VPWR sky130_fd_sc_hd__fill_2
XFILLER_85_547 VGND VGND VPWR VPWR sky130_fd_sc_hd__decap_3
XFILLER_85_558 VGND VGND VPWR VPWR sky130_fd_sc_hd__fill_2
XFILLER_85_569 VGND VGND VPWR VPWR sky130_fd_sc_hd__decap_3
Xhold1226 _7343_/Q VGND VGND VPWR VPWR _4471_/A0 sky130_fd_sc_hd__dlygate4sd3_1
XTAP_TAPCELL_ROW_56_929 VGND VPWR sky130_fd_sc_hd__tapvpwrvgnd_1
XTAP_TAPCELL_ROW_56_918 VGND VPWR sky130_fd_sc_hd__tapvpwrvgnd_1
XFILLER_25_102 VGND VGND VPWR VPWR sky130_fd_sc_hd__fill_2
XFILLER_25_113 VGND VGND VPWR VPWR sky130_fd_sc_hd__fill_1
XFILLER_53_411 VGND VGND VPWR VPWR sky130_fd_sc_hd__decap_3
XFILLER_53_433 VGND VGND VPWR VPWR sky130_fd_sc_hd__decap_3
XTAP_TAPCELL_ROW_0_245 VGND VPWR sky130_fd_sc_hd__tapvpwrvgnd_1
XTAP_TAPCELL_ROW_0_234 VGND VPWR sky130_fd_sc_hd__tapvpwrvgnd_1
XFILLER_25_157 VGND VGND VPWR VPWR sky130_fd_sc_hd__decap_3
XFILLER_80_230 VGND VGND VPWR VPWR sky130_fd_sc_hd__fill_1
X_6986_ _7364_/CLK _6986_/D _6266_/Y VGND VGND VPWR VPWR _6986_/Q sky130_fd_sc_hd__dfrtp_2
XTAP_TAPCELL_ROW_0_256 VGND VPWR sky130_fd_sc_hd__tapvpwrvgnd_1
XFILLER_15_36 VGND VGND VPWR VPWR sky130_fd_sc_hd__decap_3
XFILLER_40_105 VGND VGND VPWR VPWR sky130_fd_sc_hd__decap_3
XFILLER_41_617 VGND VGND VPWR VPWR sky130_fd_sc_hd__fill_2
XFILLER_41_639 VGND VGND VPWR VPWR sky130_fd_sc_hd__decap_3
XFILLER_53_477 VGND VGND VPWR VPWR sky130_fd_sc_hd__decap_3
XFILLER_80_285 VGND VGND VPWR VPWR sky130_fd_sc_hd__decap_3
XTAP_TAPCELL_ROW_36_686 VGND VPWR sky130_fd_sc_hd__tapvpwrvgnd_1
XFILLER_15_69 VGND VGND VPWR VPWR sky130_fd_sc_hd__decap_3
XFILLER_33_190 VGND VGND VPWR VPWR sky130_fd_sc_hd__decap_3
XFILLER_40_138 VGND VGND VPWR VPWR sky130_fd_sc_hd__fill_2
XFILLER_21_352 VGND VGND VPWR VPWR sky130_fd_sc_hd__decap_3
XFILLER_21_396 VGND VGND VPWR VPWR sky130_fd_sc_hd__decap_3
XFILLER_31_24 VGND VGND VPWR VPWR sky130_fd_sc_hd__decap_3
X_4819_ _7002_/Q _4834_/A _4818_/Y _4983_/A VGND VGND VPWR VPWR _4819_/X sky130_fd_sc_hd__o211a_2
XTAP_TAPCELL_ROW_97_1419 VGND VPWR sky130_fd_sc_hd__tapvpwrvgnd_1
XFILLER_31_46 VGND VGND VPWR VPWR sky130_fd_sc_hd__decap_3
XFILLER_31_57 VGND VGND VPWR VPWR sky130_fd_sc_hd__decap_3
XFILLER_110_6 VGND VGND VPWR VPWR sky130_fd_sc_hd__decap_3
XTAP_TAPCELL_ROW_8_345 VGND VPWR sky130_fd_sc_hd__tapvpwrvgnd_1
XFILLER_103_641 VGND VGND VPWR VPWR sky130_fd_sc_hd__decap_3
XFILLER_88_341 VGND VGND VPWR VPWR sky130_fd_sc_hd__decap_3
XFILLER_0_289 VGND VGND VPWR VPWR sky130_fd_sc_hd__decap_3
XFILLER_102_195 VGND VGND VPWR VPWR sky130_fd_sc_hd__fill_1
XFILLER_56_32 VGND VGND VPWR VPWR sky130_fd_sc_hd__fill_1
XFILLER_76_536 VGND VGND VPWR VPWR sky130_fd_sc_hd__decap_3
XFILLER_76_569 VGND VGND VPWR VPWR sky130_fd_sc_hd__fill_1
XFILLER_29_452 VGND VGND VPWR VPWR sky130_fd_sc_hd__decap_3
XFILLER_56_54 VGND VGND VPWR VPWR sky130_fd_sc_hd__decap_3
XFILLER_63_208 VGND VGND VPWR VPWR sky130_fd_sc_hd__decap_3
XFILLER_91_517 VGND VGND VPWR VPWR sky130_fd_sc_hd__decap_3
XFILLER_56_271 VGND VGND VPWR VPWR sky130_fd_sc_hd__decap_3
XTAP_TAPCELL_ROW_106_1526 VGND VPWR sky130_fd_sc_hd__tapvpwrvgnd_1
XFILLER_17_658 VGND VGND VPWR VPWR sky130_fd_sc_hd__fill_2
XFILLER_32_606 VGND VGND VPWR VPWR sky130_fd_sc_hd__fill_2
XFILLER_44_433 VGND VGND VPWR VPWR sky130_fd_sc_hd__decap_3
XFILLER_71_230 VGND VGND VPWR VPWR sky130_fd_sc_hd__decap_3
XPHY_EDGE_ROW_19_Right_19 VGND VGND VPWR VPWR sky130_fd_sc_hd__decap_3
XFILLER_112_71 VGND VGND VPWR VPWR sky130_fd_sc_hd__decap_3
XFILLER_16_179 VGND VGND VPWR VPWR sky130_fd_sc_hd__decap_3
XFILLER_31_116 VGND VGND VPWR VPWR sky130_fd_sc_hd__decap_3
XFILLER_44_477 VGND VGND VPWR VPWR sky130_fd_sc_hd__decap_3
XFILLER_31_138 VGND VGND VPWR VPWR sky130_fd_sc_hd__decap_3
XFILLER_72_64 VGND VGND VPWR VPWR sky130_fd_sc_hd__decap_3
XFILLER_12_352 VGND VGND VPWR VPWR sky130_fd_sc_hd__decap_3
XFILLER_75_9 VGND VGND VPWR VPWR sky130_fd_sc_hd__decap_3
XFILLER_8_378 VGND VGND VPWR VPWR sky130_fd_sc_hd__decap_3
Xclkbuf_3_1__f_clk clkbuf_0_clk/X VGND VGND VPWR VPWR clkbuf_leaf_1_clk/A sky130_fd_sc_hd__clkbuf_16
XPHY_EDGE_ROW_28_Right_28 VGND VGND VPWR VPWR sky130_fd_sc_hd__decap_3
XFILLER_99_617 VGND VGND VPWR VPWR sky130_fd_sc_hd__decap_3
XFILLER_4_584 VGND VGND VPWR VPWR sky130_fd_sc_hd__decap_3
XFILLER_98_138 VGND VGND VPWR VPWR sky130_fd_sc_hd__fill_2
XFILLER_98_105 VGND VGND VPWR VPWR sky130_fd_sc_hd__decap_3
XFILLER_106_490 VGND VGND VPWR VPWR sky130_fd_sc_hd__decap_3
XFILLER_113_449 VGND VGND VPWR VPWR sky130_fd_sc_hd__decap_3
XFILLER_97_61 VGND VGND VPWR VPWR sky130_fd_sc_hd__decap_3
XFILLER_39_238 VGND VGND VPWR VPWR sky130_fd_sc_hd__decap_3
XFILLER_35_411 VGND VGND VPWR VPWR sky130_fd_sc_hd__decap_3
XFILLER_82_528 VGND VGND VPWR VPWR sky130_fd_sc_hd__decap_3
XPHY_EDGE_ROW_37_Right_37 VGND VGND VPWR VPWR sky130_fd_sc_hd__decap_3
XFILLER_47_293 VGND VGND VPWR VPWR sky130_fd_sc_hd__decap_3
X_6840_ _6975_/CLK _6840_/D VGND VGND VPWR VPWR _6840_/Q sky130_fd_sc_hd__dfxtp_2
XFILLER_62_274 VGND VGND VPWR VPWR sky130_fd_sc_hd__decap_3
X_6771_ _6978_/CLK _6771_/D VGND VGND VPWR VPWR _6771_/Q sky130_fd_sc_hd__dfxtp_2
XFILLER_50_458 VGND VGND VPWR VPWR sky130_fd_sc_hd__fill_2
X_3983_ _7349_/Q _4524_/A0 _3996_/S VGND VGND VPWR VPWR _3983_/X sky130_fd_sc_hd__mux2_2
XTAP_TAPCELL_ROW_33_645 VGND VPWR sky130_fd_sc_hd__tapvpwrvgnd_1
XFILLER_31_661 VGND VGND VPWR VPWR sky130_fd_sc_hd__decap_3
XTAP_TAPCELL_ROW_61_987 VGND VPWR sky130_fd_sc_hd__tapvpwrvgnd_1
XFILLER_30_171 VGND VGND VPWR VPWR sky130_fd_sc_hd__decap_3
X_5653_ _5664_/B VGND VGND VPWR VPWR _5653_/Y sky130_fd_sc_hd__inv_2
X_4604_ _4667_/B VGND VGND VPWR VPWR _4671_/B sky130_fd_sc_hd__inv_2
XPHY_EDGE_ROW_46_Right_46 VGND VGND VPWR VPWR sky130_fd_sc_hd__decap_3
XFILLER_7_81 VGND VGND VPWR VPWR sky130_fd_sc_hd__decap_3
X_7323_ clkload3/A _7323_/D _6603_/Y VGND VGND VPWR VPWR _7323_/Q sky130_fd_sc_hd__dfrtp_2
XFILLER_116_243 VGND VGND VPWR VPWR sky130_fd_sc_hd__fill_1
XFILLER_116_265 VGND VGND VPWR VPWR sky130_fd_sc_hd__decap_3
XFILLER_116_298 VGND VGND VPWR VPWR sky130_fd_sc_hd__decap_3
XFILLER_89_105 VGND VGND VPWR VPWR sky130_fd_sc_hd__decap_3
X_7254_ clkload5/A _7254_/D _6534_/Y VGND VGND VPWR VPWR _7254_/Q sky130_fd_sc_hd__dfrtp_2
X_4466_ _4466_/A _5650_/A VGND VGND VPWR VPWR _4466_/Y sky130_fd_sc_hd__nand2_2
XFILLER_89_149 VGND VGND VPWR VPWR sky130_fd_sc_hd__decap_3
X_7185_ clkload9/A _7185_/D _6465_/Y VGND VGND VPWR VPWR _7185_/Q sky130_fd_sc_hd__dfrtp_2
X_4397_ _4397_/A _4648_/A VGND VGND VPWR VPWR _4647_/C sky130_fd_sc_hd__nor2_2
X_3417_ _3449_/B _3421_/C _3417_/C VGND VGND VPWR VPWR _3417_/X sky130_fd_sc_hd__and3_2
XFILLER_58_503 VGND VGND VPWR VPWR sky130_fd_sc_hd__decap_3
XFILLER_97_160 VGND VGND VPWR VPWR sky130_fd_sc_hd__decap_3
X_3348_ _3371_/A _3365_/A _3342_/B VGND VGND VPWR VPWR _5130_/A sky130_fd_sc_hd__a21oi_2
XTAP_TAPCELL_ROW_5_315 VGND VPWR sky130_fd_sc_hd__tapvpwrvgnd_1
XFILLER_98_672 VGND VGND VPWR VPWR sky130_fd_sc_hd__decap_3
XFILLER_85_311 VGND VGND VPWR VPWR sky130_fd_sc_hd__decap_3
Xhold1001 _7054_/Q VGND VGND VPWR VPWR _5561_/A1 sky130_fd_sc_hd__dlygate4sd3_1
Xhold1012 _7200_/Q VGND VGND VPWR VPWR _5260_/A0 sky130_fd_sc_hd__dlygate4sd3_1
Xhold1023 _7273_/Q VGND VGND VPWR VPWR _4807_/A0 sky130_fd_sc_hd__dlygate4sd3_1
XFILLER_100_666 VGND VGND VPWR VPWR sky130_fd_sc_hd__decap_3
XFILLER_58_569 VGND VGND VPWR VPWR sky130_fd_sc_hd__decap_3
Xhold1034 _7039_/Q VGND VGND VPWR VPWR _5579_/A0 sky130_fd_sc_hd__dlygate4sd3_1
Xhold1045 _7386_/Q VGND VGND VPWR VPWR _3860_/A0 sky130_fd_sc_hd__dlygate4sd3_1
Xhold1056 _6716_/Q VGND VGND VPWR VPWR _5733_/A1 sky130_fd_sc_hd__dlygate4sd3_1
Xhold1067 _7241_/Q VGND VGND VPWR VPWR _5173_/A sky130_fd_sc_hd__dlygate4sd3_1
XPHY_EDGE_ROW_55_Right_55 VGND VGND VPWR VPWR sky130_fd_sc_hd__decap_3
XFILLER_26_24 VGND VGND VPWR VPWR sky130_fd_sc_hd__decap_3
XFILLER_26_400 VGND VGND VPWR VPWR sky130_fd_sc_hd__decap_3
XFILLER_26_411 VGND VGND VPWR VPWR sky130_fd_sc_hd__fill_1
Xhold1078 _7189_/Q VGND VGND VPWR VPWR _5282_/A1 sky130_fd_sc_hd__dlygate4sd3_1
Xhold1089 _7331_/Q VGND VGND VPWR VPWR _4497_/A0 sky130_fd_sc_hd__dlygate4sd3_1
X_5018_ _5018_/A _5018_/B VGND VGND VPWR VPWR _5018_/Y sky130_fd_sc_hd__nor2_2
XFILLER_26_57 VGND VGND VPWR VPWR sky130_fd_sc_hd__decap_3
XFILLER_38_293 VGND VGND VPWR VPWR sky130_fd_sc_hd__decap_3
XFILLER_26_477 VGND VGND VPWR VPWR sky130_fd_sc_hd__decap_3
XFILLER_41_403 VGND VGND VPWR VPWR sky130_fd_sc_hd__decap_3
XFILLER_53_252 VGND VGND VPWR VPWR sky130_fd_sc_hd__decap_3
XFILLER_13_116 VGND VGND VPWR VPWR sky130_fd_sc_hd__fill_1
X_6969_ _6976_/CLK _6969_/D VGND VGND VPWR VPWR _6969_/Q sky130_fd_sc_hd__dfxtp_2
XFILLER_22_661 VGND VGND VPWR VPWR sky130_fd_sc_hd__decap_3
XFILLER_42_12 VGND VGND VPWR VPWR sky130_fd_sc_hd__decap_3
XFILLER_42_34 VGND VGND VPWR VPWR sky130_fd_sc_hd__decap_3
XTAP_TAPCELL_ROW_101_1467 VGND VPWR sky130_fd_sc_hd__tapvpwrvgnd_1
XPHY_EDGE_ROW_64_Right_64 VGND VGND VPWR VPWR sky130_fd_sc_hd__decap_3
XFILLER_5_348 VGND VGND VPWR VPWR sky130_fd_sc_hd__decap_3
XFILLER_107_276 VGND VGND VPWR VPWR sky130_fd_sc_hd__fill_1
XFILLER_107_287 VGND VGND VPWR VPWR sky130_fd_sc_hd__decap_3
XFILLER_89_650 VGND VGND VPWR VPWR sky130_fd_sc_hd__decap_3
Xhold890 _7078_/Q VGND VGND VPWR VPWR _7078_/D sky130_fd_sc_hd__dlygate4sd3_1
XFILLER_107_60 VGND VGND VPWR VPWR sky130_fd_sc_hd__decap_3
XFILLER_107_93 VGND VGND VPWR VPWR sky130_fd_sc_hd__decap_3
XFILLER_3_39 VGND VGND VPWR VPWR sky130_fd_sc_hd__decap_3
XFILLER_95_119 VGND VGND VPWR VPWR sky130_fd_sc_hd__decap_3
XFILLER_67_42 VGND VGND VPWR VPWR sky130_fd_sc_hd__decap_3
XFILLER_76_333 VGND VGND VPWR VPWR sky130_fd_sc_hd__decap_3
XTAP_TAPCELL_ROW_112_1596 VGND VPWR sky130_fd_sc_hd__tapvpwrvgnd_1
XPHY_EDGE_ROW_73_Right_73 VGND VGND VPWR VPWR sky130_fd_sc_hd__decap_3
XFILLER_49_569 VGND VGND VPWR VPWR sky130_fd_sc_hd__decap_3
XFILLER_76_355 VGND VGND VPWR VPWR sky130_fd_sc_hd__decap_3
XFILLER_57_591 VGND VGND VPWR VPWR sky130_fd_sc_hd__decap_3
XFILLER_64_539 VGND VGND VPWR VPWR sky130_fd_sc_hd__fill_1
XFILLER_83_63 VGND VGND VPWR VPWR sky130_fd_sc_hd__decap_3
XTAP_TAPCELL_ROW_67_1053 VGND VPWR sky130_fd_sc_hd__tapvpwrvgnd_1
XFILLER_32_447 VGND VGND VPWR VPWR sky130_fd_sc_hd__decap_3
XPHY_EDGE_ROW_17_Left_134 VGND VGND VPWR VPWR sky130_fd_sc_hd__decap_3
XFILLER_13_650 VGND VGND VPWR VPWR sky130_fd_sc_hd__decap_3
XPHY_EDGE_ROW_82_Right_82 VGND VGND VPWR VPWR sky130_fd_sc_hd__decap_3
XTAP_TAPCELL_ROW_30_615 VGND VPWR sky130_fd_sc_hd__tapvpwrvgnd_1
XFILLER_73_6 VGND VGND VPWR VPWR sky130_fd_sc_hd__decap_3
XFILLER_9_676 VGND VGND VPWR VPWR sky130_fd_sc_hd__decap_3
XFILLER_9_654 VGND VGND VPWR VPWR sky130_fd_sc_hd__decap_3
XFILLER_8_197 VGND VGND VPWR VPWR sky130_fd_sc_hd__decap_3
XTAP_TAPCELL_ROW_10_372 VGND VPWR sky130_fd_sc_hd__tapvpwrvgnd_1
XFILLER_113_202 VGND VGND VPWR VPWR sky130_fd_sc_hd__decap_3
X_4320_ _7066_/Q _4265_/B _4205_/A VGND VGND VPWR VPWR _4362_/B sky130_fd_sc_hd__o21a_2
XTAP_TAPCELL_ROW_78_1193 VGND VPWR sky130_fd_sc_hd__tapvpwrvgnd_1
XTAP_TAPCELL_ROW_78_1182 VGND VPWR sky130_fd_sc_hd__tapvpwrvgnd_1
XFILLER_113_246 VGND VGND VPWR VPWR sky130_fd_sc_hd__decap_3
XFILLER_87_609 VGND VGND VPWR VPWR sky130_fd_sc_hd__decap_3
X_4251_ _7016_/Q _4356_/A2 _4351_/B1 _7133_/Q _4250_/X VGND VGND VPWR VPWR _4251_/X
+ sky130_fd_sc_hd__a221o_2
XPHY_EDGE_ROW_26_Left_143 VGND VGND VPWR VPWR sky130_fd_sc_hd__decap_3
XFILLER_113_279 VGND VGND VPWR VPWR sky130_fd_sc_hd__fill_1
XFILLER_86_119 VGND VGND VPWR VPWR sky130_fd_sc_hd__decap_3
XPHY_EDGE_ROW_91_Right_91 VGND VGND VPWR VPWR sky130_fd_sc_hd__decap_3
XFILLER_95_620 VGND VGND VPWR VPWR sky130_fd_sc_hd__decap_3
X_4182_ _7136_/Q _4195_/A2 _4180_/X _4181_/X VGND VGND VPWR VPWR _4182_/X sky130_fd_sc_hd__a211o_2
XFILLER_94_141 VGND VGND VPWR VPWR sky130_fd_sc_hd__decap_3
XFILLER_95_653 VGND VGND VPWR VPWR sky130_fd_sc_hd__decap_3
XTAP_TAPCELL_ROW_38_704 VGND VPWR sky130_fd_sc_hd__tapvpwrvgnd_1
XFILLER_103_18 VGND VGND VPWR VPWR sky130_fd_sc_hd__decap_3
XFILLER_48_580 VGND VGND VPWR VPWR sky130_fd_sc_hd__decap_3
XFILLER_94_163 VGND VGND VPWR VPWR sky130_fd_sc_hd__decap_3
XFILLER_94_185 VGND VGND VPWR VPWR sky130_fd_sc_hd__decap_3
XFILLER_50_200 VGND VGND VPWR VPWR sky130_fd_sc_hd__decap_3
XPHY_EDGE_ROW_35_Left_152 VGND VGND VPWR VPWR sky130_fd_sc_hd__decap_3
XFILLER_23_447 VGND VGND VPWR VPWR sky130_fd_sc_hd__fill_1
XFILLER_50_222 VGND VGND VPWR VPWR sky130_fd_sc_hd__decap_3
X_6823_ _6946_/CLK _6823_/D VGND VGND VPWR VPWR _6823_/Q sky130_fd_sc_hd__dfxtp_2
XTAP_TAPCELL_ROW_18_472 VGND VPWR sky130_fd_sc_hd__tapvpwrvgnd_1
X_6754_ _6965_/CLK _6754_/D VGND VGND VPWR VPWR _6754_/Q sky130_fd_sc_hd__dfxtp_2
X_3966_ _7357_/Q _3966_/A1 _3968_/S VGND VGND VPWR VPWR _7357_/D sky130_fd_sc_hd__mux2_2
XFILLER_31_480 VGND VGND VPWR VPWR sky130_fd_sc_hd__fill_1
XFILLER_50_277 VGND VGND VPWR VPWR sky130_fd_sc_hd__decap_3
X_6685_ _6686_/A VGND VGND VPWR VPWR _6685_/Y sky130_fd_sc_hd__inv_2
X_5705_ hold907/X _5721_/S _4270_/Y VGND VGND VPWR VPWR _6702_/D sky130_fd_sc_hd__a21bo_2
XFILLER_12_15 VGND VGND VPWR VPWR sky130_fd_sc_hd__decap_3
X_3897_ hold959/X _5104_/A _3896_/Y VGND VGND VPWR VPWR _7382_/D sky130_fd_sc_hd__a21bo_2
XFILLER_12_59 VGND VGND VPWR VPWR sky130_fd_sc_hd__decap_3
X_5567_ hold945/X _4909_/A _4870_/Y VGND VGND VPWR VPWR _7050_/D sky130_fd_sc_hd__a21o_2
XFILLER_2_318 VGND VGND VPWR VPWR sky130_fd_sc_hd__decap_3
X_7306_ _7402_/CLK _7306_/D _6586_/Y VGND VGND VPWR VPWR _7306_/Q sky130_fd_sc_hd__dfrtp_2
XPHY_EDGE_ROW_44_Left_161 VGND VGND VPWR VPWR sky130_fd_sc_hd__decap_3
XFILLER_5_9 VGND VGND VPWR VPWR sky130_fd_sc_hd__decap_3
X_7237_ _7368_/CLK _7237_/D _6517_/Y VGND VGND VPWR VPWR _7237_/Q sky130_fd_sc_hd__dfrtp_2
X_4449_ _4403_/A _4411_/B _4448_/X VGND VGND VPWR VPWR _4761_/C sky130_fd_sc_hd__a21oi_2
XFILLER_104_279 VGND VGND VPWR VPWR sky130_fd_sc_hd__fill_2
XFILLER_77_119 VGND VGND VPWR VPWR sky130_fd_sc_hd__decap_3
XFILLER_58_333 VGND VGND VPWR VPWR sky130_fd_sc_hd__decap_3
XFILLER_86_642 VGND VGND VPWR VPWR sky130_fd_sc_hd__fill_2
X_7168_ _7294_/CLK _7168_/D _6448_/Y VGND VGND VPWR VPWR _7168_/Q sky130_fd_sc_hd__dfrtp_2
XFILLER_37_12 VGND VGND VPWR VPWR sky130_fd_sc_hd__decap_3
XFILLER_86_675 VGND VGND VPWR VPWR sky130_fd_sc_hd__decap_3
X_7099_ clkload5/A _7099_/D _6379_/Y VGND VGND VPWR VPWR _7099_/Q sky130_fd_sc_hd__dfrtp_2
XFILLER_100_463 VGND VGND VPWR VPWR sky130_fd_sc_hd__decap_3
XFILLER_18_208 VGND VGND VPWR VPWR sky130_fd_sc_hd__decap_3
XFILLER_46_528 VGND VGND VPWR VPWR sky130_fd_sc_hd__decap_3
XFILLER_58_377 VGND VGND VPWR VPWR sky130_fd_sc_hd__decap_3
XFILLER_73_314 VGND VGND VPWR VPWR sky130_fd_sc_hd__fill_1
XFILLER_85_196 VGND VGND VPWR VPWR sky130_fd_sc_hd__decap_3
XPHY_EDGE_ROW_53_Left_170 VGND VGND VPWR VPWR sky130_fd_sc_hd__decap_3
XFILLER_54_561 VGND VGND VPWR VPWR sky130_fd_sc_hd__fill_1
XFILLER_26_274 VGND VGND VPWR VPWR sky130_fd_sc_hd__decap_3
XFILLER_26_296 VGND VGND VPWR VPWR sky130_fd_sc_hd__decap_3
XFILLER_54_583 VGND VGND VPWR VPWR sky130_fd_sc_hd__decap_3
XFILLER_22_480 VGND VGND VPWR VPWR sky130_fd_sc_hd__decap_3
XFILLER_10_642 VGND VGND VPWR VPWR sky130_fd_sc_hd__fill_2
XFILLER_10_653 VGND VGND VPWR VPWR sky130_fd_sc_hd__decap_3
XFILLER_10_686 VGND VGND VPWR VPWR sky130_fd_sc_hd__decap_3
XFILLER_5_134 VGND VGND VPWR VPWR sky130_fd_sc_hd__decap_3
XFILLER_6_679 VGND VGND VPWR VPWR sky130_fd_sc_hd__decap_3
XFILLER_5_167 VGND VGND VPWR VPWR sky130_fd_sc_hd__fill_1
XFILLER_5_189 VGND VGND VPWR VPWR sky130_fd_sc_hd__decap_3
XTAP_TAPCELL_ROW_114_1625 VGND VPWR sky130_fd_sc_hd__tapvpwrvgnd_1
XTAP_TAPCELL_ROW_114_1614 VGND VPWR sky130_fd_sc_hd__tapvpwrvgnd_1
XFILLER_69_609 VGND VGND VPWR VPWR sky130_fd_sc_hd__decap_3
XFILLER_38_9 VGND VGND VPWR VPWR sky130_fd_sc_hd__decap_3
XFILLER_78_63 VGND VGND VPWR VPWR sky130_fd_sc_hd__fill_2
XFILLER_78_85 VGND VGND VPWR VPWR sky130_fd_sc_hd__decap_3
XFILLER_1_373 VGND VGND VPWR VPWR sky130_fd_sc_hd__decap_3
XFILLER_49_322 VGND VGND VPWR VPWR sky130_fd_sc_hd__decap_3
XFILLER_77_642 VGND VGND VPWR VPWR sky130_fd_sc_hd__decap_3
XFILLER_89_480 VGND VGND VPWR VPWR sky130_fd_sc_hd__fill_2
XFILLER_103_290 VGND VGND VPWR VPWR sky130_fd_sc_hd__decap_3
XFILLER_76_141 VGND VGND VPWR VPWR sky130_fd_sc_hd__decap_3
XFILLER_64_303 VGND VGND VPWR VPWR sky130_fd_sc_hd__decap_3
XFILLER_76_174 VGND VGND VPWR VPWR sky130_fd_sc_hd__fill_1
XFILLER_92_623 VGND VGND VPWR VPWR sky130_fd_sc_hd__decap_3
XFILLER_94_40 VGND VGND VPWR VPWR sky130_fd_sc_hd__decap_3
XFILLER_91_122 VGND VGND VPWR VPWR sky130_fd_sc_hd__decap_3
XFILLER_92_645 VGND VGND VPWR VPWR sky130_fd_sc_hd__decap_3
XFILLER_17_252 VGND VGND VPWR VPWR sky130_fd_sc_hd__decap_3
XFILLER_45_561 VGND VGND VPWR VPWR sky130_fd_sc_hd__decap_3
XFILLER_92_678 VGND VGND VPWR VPWR sky130_fd_sc_hd__decap_3
XFILLER_32_200 VGND VGND VPWR VPWR sky130_fd_sc_hd__decap_3
XFILLER_32_222 VGND VGND VPWR VPWR sky130_fd_sc_hd__decap_3
X_3820_ _6927_/Q _3926_/A2 _3925_/A2 _6701_/Q VGND VGND VPWR VPWR _3820_/X sky130_fd_sc_hd__a22o_2
XTAP_TAPCELL_ROW_43_762 VGND VPWR sky130_fd_sc_hd__tapvpwrvgnd_1
XTAP_TAPCELL_ROW_15_431 VGND VPWR sky130_fd_sc_hd__tapvpwrvgnd_1
XFILLER_20_439 VGND VGND VPWR VPWR sky130_fd_sc_hd__fill_1
XFILLER_32_277 VGND VGND VPWR VPWR sky130_fd_sc_hd__decap_3
X_3751_ _6935_/Q _3768_/A2 _3767_/B1 _6887_/Q VGND VGND VPWR VPWR _3751_/X sky130_fd_sc_hd__a22o_2
XTAP_TAPCELL_ROW_43_773 VGND VPWR sky130_fd_sc_hd__tapvpwrvgnd_1
XFILLER_71_3 VGND VGND VPWR VPWR sky130_fd_sc_hd__decap_3
X_6470_ _6562_/A VGND VGND VPWR VPWR _6470_/Y sky130_fd_sc_hd__inv_2
X_3682_ _3682_/A _3682_/B VGND VGND VPWR VPWR _3682_/Y sky130_fd_sc_hd__nand2_2
XFILLER_9_484 VGND VGND VPWR VPWR sky130_fd_sc_hd__decap_3
X_5421_ _7123_/Q _5135_/X _5423_/S VGND VGND VPWR VPWR _7123_/D sky130_fd_sc_hd__mux2_2
XFILLER_114_500 VGND VGND VPWR VPWR sky130_fd_sc_hd__decap_3
X_5352_ _5352_/A0 _5135_/X _5358_/S VGND VGND VPWR VPWR _7155_/D sky130_fd_sc_hd__mux2_2
XFILLER_114_533 VGND VGND VPWR VPWR sky130_fd_sc_hd__decap_3
X_4303_ _7320_/Q _3977_/S _4303_/B1 _7128_/Q _4302_/X VGND VGND VPWR VPWR _4303_/X
+ sky130_fd_sc_hd__a221o_2
XFILLER_99_233 VGND VGND VPWR VPWR sky130_fd_sc_hd__decap_3
XFILLER_114_566 VGND VGND VPWR VPWR sky130_fd_sc_hd__decap_3
XFILLER_59_108 VGND VGND VPWR VPWR sky130_fd_sc_hd__decap_3
XFILLER_87_417 VGND VGND VPWR VPWR sky130_fd_sc_hd__decap_3
X_7022_ _7337_/CLK _7022_/D _6302_/Y VGND VGND VPWR VPWR _7022_/Q sky130_fd_sc_hd__dfrtp_2
X_5283_ _3600_/A _4788_/A _5238_/X hold994/X VGND VGND VPWR VPWR _7188_/D sky130_fd_sc_hd__a22o_2
XFILLER_99_266 VGND VGND VPWR VPWR sky130_fd_sc_hd__decap_3
XFILLER_4_71 VGND VGND VPWR VPWR sky130_fd_sc_hd__decap_3
X_4234_ _7355_/Q _4338_/B1 _4233_/X _3556_/A VGND VGND VPWR VPWR _4234_/X sky130_fd_sc_hd__a211o_2
XFILLER_68_675 VGND VGND VPWR VPWR sky130_fd_sc_hd__decap_3
XFILLER_83_601 VGND VGND VPWR VPWR sky130_fd_sc_hd__decap_3
X_4165_ _7018_/Q _4418_/A2 _4195_/A2 _7137_/Q _4164_/X VGND VGND VPWR VPWR _4165_/X
+ sky130_fd_sc_hd__a221o_2
XFILLER_28_539 VGND VGND VPWR VPWR sky130_fd_sc_hd__fill_2
XFILLER_83_623 VGND VGND VPWR VPWR sky130_fd_sc_hd__decap_3
XFILLER_82_144 VGND VGND VPWR VPWR sky130_fd_sc_hd__fill_2
XFILLER_83_656 VGND VGND VPWR VPWR sky130_fd_sc_hd__decap_3
X_4096_ _4096_/A _4096_/B VGND VGND VPWR VPWR _4633_/A sky130_fd_sc_hd__nand2_2
XFILLER_36_550 VGND VGND VPWR VPWR sky130_fd_sc_hd__decap_3
XFILLER_36_572 VGND VGND VPWR VPWR sky130_fd_sc_hd__decap_3
XFILLER_43_509 VGND VGND VPWR VPWR sky130_fd_sc_hd__decap_3
XFILLER_23_211 VGND VGND VPWR VPWR sky130_fd_sc_hd__decap_3
XFILLER_23_233 VGND VGND VPWR VPWR sky130_fd_sc_hd__fill_2
XFILLER_23_255 VGND VGND VPWR VPWR sky130_fd_sc_hd__decap_3
XFILLER_51_542 VGND VGND VPWR VPWR sky130_fd_sc_hd__fill_2
XFILLER_51_553 VGND VGND VPWR VPWR sky130_fd_sc_hd__decap_3
Xplace391 _5642_/A VGND VGND VPWR VPWR _5666_/A sky130_fd_sc_hd__buf_2
Xplace380 _3378_/Y VGND VGND VPWR VPWR _4348_/B1 sky130_fd_sc_hd__buf_2
X_6806_ _6944_/CLK _6806_/D VGND VGND VPWR VPWR _6806_/Q sky130_fd_sc_hd__dfxtp_2
XFILLER_11_439 VGND VGND VPWR VPWR sky130_fd_sc_hd__fill_1
XFILLER_23_36 VGND VGND VPWR VPWR sky130_fd_sc_hd__decap_3
X_4998_ _4998_/A0 _4997_/X _5028_/S VGND VGND VPWR VPWR _7262_/D sky130_fd_sc_hd__mux2_2
XFILLER_23_69 VGND VGND VPWR VPWR sky130_fd_sc_hd__decap_3
X_6737_ _7392_/CLK _6737_/D VGND VGND VPWR VPWR _6737_/Q sky130_fd_sc_hd__dfxtp_2
X_3949_ _7365_/Q _4493_/A0 _3954_/S VGND VGND VPWR VPWR _7365_/D sky130_fd_sc_hd__mux2_2
X_6668_ _6670_/A VGND VGND VPWR VPWR _6668_/Y sky130_fd_sc_hd__inv_2
X_6599_ _6599_/A VGND VGND VPWR VPWR _6599_/Y sky130_fd_sc_hd__inv_2
X_5619_ _5619_/A _5622_/B VGND VGND VPWR VPWR _7018_/D sky130_fd_sc_hd__or2_2
XFILLER_3_605 VGND VGND VPWR VPWR sky130_fd_sc_hd__decap_3
XFILLER_105_522 VGND VGND VPWR VPWR sky130_fd_sc_hd__decap_3
XFILLER_2_115 VGND VGND VPWR VPWR sky130_fd_sc_hd__decap_3
XFILLER_3_6 VGND VGND VPWR VPWR sky130_fd_sc_hd__decap_3
XFILLER_3_649 VGND VGND VPWR VPWR sky130_fd_sc_hd__decap_3
XFILLER_2_159 VGND VGND VPWR VPWR sky130_fd_sc_hd__fill_1
XFILLER_59_620 VGND VGND VPWR VPWR sky130_fd_sc_hd__decap_3
XFILLER_48_66 VGND VGND VPWR VPWR sky130_fd_sc_hd__decap_3
XFILLER_58_141 VGND VGND VPWR VPWR sky130_fd_sc_hd__decap_3
XFILLER_59_653 VGND VGND VPWR VPWR sky130_fd_sc_hd__decap_3
XFILLER_46_303 VGND VGND VPWR VPWR sky130_fd_sc_hd__decap_3
XFILLER_74_601 VGND VGND VPWR VPWR sky130_fd_sc_hd__decap_3
XFILLER_0_29 VGND VGND VPWR VPWR sky130_fd_sc_hd__decap_3
XFILLER_100_282 VGND VGND VPWR VPWR sky130_fd_sc_hd__decap_3
XFILLER_64_21 VGND VGND VPWR VPWR sky130_fd_sc_hd__decap_3
XFILLER_73_133 VGND VGND VPWR VPWR sky130_fd_sc_hd__decap_3
XFILLER_74_645 VGND VGND VPWR VPWR sky130_fd_sc_hd__decap_3
XFILLER_104_83 VGND VGND VPWR VPWR sky130_fd_sc_hd__fill_1
XFILLER_104_94 VGND VGND VPWR VPWR sky130_fd_sc_hd__decap_3
XFILLER_27_561 VGND VGND VPWR VPWR sky130_fd_sc_hd__decap_3
XFILLER_64_43 VGND VGND VPWR VPWR sky130_fd_sc_hd__decap_3
XFILLER_74_678 VGND VGND VPWR VPWR sky130_fd_sc_hd__decap_3
XFILLER_14_200 VGND VGND VPWR VPWR sky130_fd_sc_hd__decap_3
XFILLER_42_531 VGND VGND VPWR VPWR sky130_fd_sc_hd__fill_1
XFILLER_54_380 VGND VGND VPWR VPWR sky130_fd_sc_hd__decap_3
XFILLER_61_328 VGND VGND VPWR VPWR sky130_fd_sc_hd__decap_3
XTAP_TAPCELL_ROW_64_1023 VGND VPWR sky130_fd_sc_hd__tapvpwrvgnd_1
XFILLER_14_233 VGND VGND VPWR VPWR sky130_fd_sc_hd__decap_3
XFILLER_9_27 VGND VGND VPWR VPWR sky130_fd_sc_hd__decap_3
XFILLER_42_586 VGND VGND VPWR VPWR sky130_fd_sc_hd__fill_2
XFILLER_42_597 VGND VGND VPWR VPWR sky130_fd_sc_hd__fill_1
XFILLER_80_42 VGND VGND VPWR VPWR sky130_fd_sc_hd__fill_2
XTAP_TAPCELL_ROW_12_401 VGND VPWR sky130_fd_sc_hd__tapvpwrvgnd_1
XFILLER_80_53 VGND VGND VPWR VPWR sky130_fd_sc_hd__fill_1
Xfanout70 _6523_/A VGND VGND VPWR VPWR _6525_/A sky130_fd_sc_hd__buf_1
XTAP_TAPCELL_ROW_40_732 VGND VPWR sky130_fd_sc_hd__tapvpwrvgnd_1
XFILLER_6_421 VGND VGND VPWR VPWR sky130_fd_sc_hd__decap_3
XFILLER_6_454 VGND VGND VPWR VPWR sky130_fd_sc_hd__decap_3
XPHY_EDGE_ROW_108_Right_108 VGND VGND VPWR VPWR sky130_fd_sc_hd__decap_3
XFILLER_108_382 VGND VGND VPWR VPWR sky130_fd_sc_hd__fill_1
XTAP_TAPCELL_ROW_75_1152 VGND VPWR sky130_fd_sc_hd__tapvpwrvgnd_1
XFILLER_111_503 VGND VGND VPWR VPWR sky130_fd_sc_hd__fill_1
XFILLER_2_660 VGND VGND VPWR VPWR sky130_fd_sc_hd__decap_3
XFILLER_89_95 VGND VGND VPWR VPWR sky130_fd_sc_hd__fill_1
XFILLER_36_6 VGND VGND VPWR VPWR sky130_fd_sc_hd__decap_3
XFILLER_69_439 VGND VGND VPWR VPWR sky130_fd_sc_hd__fill_1
XFILLER_84_409 VGND VGND VPWR VPWR sky130_fd_sc_hd__decap_3
XFILLER_65_612 VGND VGND VPWR VPWR sky130_fd_sc_hd__decap_3
XFILLER_65_623 VGND VGND VPWR VPWR sky130_fd_sc_hd__decap_3
XFILLER_77_461 VGND VGND VPWR VPWR sky130_fd_sc_hd__decap_3
XFILLER_64_111 VGND VGND VPWR VPWR sky130_fd_sc_hd__decap_3
XFILLER_64_133 VGND VGND VPWR VPWR sky130_fd_sc_hd__decap_3
XFILLER_65_656 VGND VGND VPWR VPWR sky130_fd_sc_hd__decap_3
XFILLER_92_442 VGND VGND VPWR VPWR sky130_fd_sc_hd__decap_3
XTAP_TAPCELL_ROW_48_832 VGND VPWR sky130_fd_sc_hd__tapvpwrvgnd_1
XFILLER_64_144 VGND VGND VPWR VPWR sky130_fd_sc_hd__decap_3
XFILLER_80_615 VGND VGND VPWR VPWR sky130_fd_sc_hd__decap_3
XFILLER_92_475 VGND VGND VPWR VPWR sky130_fd_sc_hd__fill_1
XFILLER_92_486 VGND VGND VPWR VPWR sky130_fd_sc_hd__fill_1
XFILLER_52_339 VGND VGND VPWR VPWR sky130_fd_sc_hd__decap_3
XFILLER_64_188 VGND VGND VPWR VPWR sky130_fd_sc_hd__decap_3
XFILLER_80_648 VGND VGND VPWR VPWR sky130_fd_sc_hd__decap_3
X_4921_ _4968_/A _4383_/C _4201_/X VGND VGND VPWR VPWR _4937_/B sky130_fd_sc_hd__a21bo_2
XTAP_TAPCELL_ROW_86_1281 VGND VPWR sky130_fd_sc_hd__tapvpwrvgnd_1
XFILLER_100_19 VGND VGND VPWR VPWR sky130_fd_sc_hd__decap_3
X_4852_ _4852_/A _5057_/A VGND VGND VPWR VPWR _5101_/A sky130_fd_sc_hd__and2_2
XFILLER_20_214 VGND VGND VPWR VPWR sky130_fd_sc_hd__decap_3
XFILLER_33_597 VGND VGND VPWR VPWR sky130_fd_sc_hd__fill_1
X_3803_ _6816_/Q _3889_/A2 _3888_/B1 _6821_/Q VGND VGND VPWR VPWR _3803_/X sky130_fd_sc_hd__a22o_2
XFILLER_60_394 VGND VGND VPWR VPWR sky130_fd_sc_hd__fill_1
X_4783_ _4646_/A _4646_/B _4827_/A VGND VGND VPWR VPWR _4829_/B sky130_fd_sc_hd__a21boi_2
X_6522_ _6522_/A VGND VGND VPWR VPWR _6522_/Y sky130_fd_sc_hd__inv_2
X_3734_ _3728_/Y _3730_/X _3732_/X _3733_/X VGND VGND VPWR VPWR _3734_/X sky130_fd_sc_hd__a22o_2
X_6453_ _6642_/A VGND VGND VPWR VPWR _6453_/Y sky130_fd_sc_hd__inv_2
X_3665_ _3665_/A _3665_/B VGND VGND VPWR VPWR _3665_/X sky130_fd_sc_hd__and2_4
XFILLER_109_39 VGND VGND VPWR VPWR sky130_fd_sc_hd__decap_3
X_5404_ _5404_/A0 _5040_/X _5423_/S VGND VGND VPWR VPWR _7131_/D sky130_fd_sc_hd__mux2_2
XFILLER_114_330 VGND VGND VPWR VPWR sky130_fd_sc_hd__decap_3
X_6384_ _6604_/A VGND VGND VPWR VPWR _6384_/Y sky130_fd_sc_hd__inv_2
X_3596_ _4295_/B _3607_/B VGND VGND VPWR VPWR _3598_/A sky130_fd_sc_hd__and2_2
XFILLER_114_363 VGND VGND VPWR VPWR sky130_fd_sc_hd__fill_1
XFILLER_102_536 VGND VGND VPWR VPWR sky130_fd_sc_hd__decap_3
XFILLER_87_225 VGND VGND VPWR VPWR sky130_fd_sc_hd__decap_3
X_5266_ _5266_/A0 _5011_/X _5274_/S VGND VGND VPWR VPWR _7197_/D sky130_fd_sc_hd__mux2_2
XFILLER_102_558 VGND VGND VPWR VPWR sky130_fd_sc_hd__decap_3
XFILLER_68_450 VGND VGND VPWR VPWR sky130_fd_sc_hd__decap_3
XFILLER_87_269 VGND VGND VPWR VPWR sky130_fd_sc_hd__decap_3
X_7005_ _7005_/CLK _7005_/D _6285_/Y VGND VGND VPWR VPWR _7005_/Q sky130_fd_sc_hd__dfrtp_2
X_4217_ _3469_/A _3469_/B _3449_/A _7015_/Q _3365_/A VGND VGND VPWR VPWR _4217_/X
+ sky130_fd_sc_hd__o2111a_2
XFILLER_56_601 VGND VGND VPWR VPWR sky130_fd_sc_hd__decap_3
XFILLER_68_472 VGND VGND VPWR VPWR sky130_fd_sc_hd__decap_3
XFILLER_55_111 VGND VGND VPWR VPWR sky130_fd_sc_hd__fill_1
XFILLER_55_133 VGND VGND VPWR VPWR sky130_fd_sc_hd__decap_3
XFILLER_56_634 VGND VGND VPWR VPWR sky130_fd_sc_hd__decap_3
XFILLER_56_645 VGND VGND VPWR VPWR sky130_fd_sc_hd__decap_3
XFILLER_95_291 VGND VGND VPWR VPWR sky130_fd_sc_hd__decap_3
X_4148_ _7074_/Q _4265_/B _4145_/X _4147_/X VGND VGND VPWR VPWR _4205_/B sky130_fd_sc_hd__o22a_2
XFILLER_43_317 VGND VGND VPWR VPWR sky130_fd_sc_hd__decap_3
XFILLER_56_689 VGND VGND VPWR VPWR sky130_fd_sc_hd__decap_3
XFILLER_71_626 VGND VGND VPWR VPWR sky130_fd_sc_hd__decap_3
X_4079_ _7403_/Q _4437_/B1 _4077_/X _4078_/X VGND VGND VPWR VPWR _4079_/X sky130_fd_sc_hd__a211o_2
XFILLER_71_659 VGND VGND VPWR VPWR sky130_fd_sc_hd__decap_3
XFILLER_83_486 VGND VGND VPWR VPWR sky130_fd_sc_hd__decap_3
XFILLER_34_24 VGND VGND VPWR VPWR sky130_fd_sc_hd__decap_3
XFILLER_70_147 VGND VGND VPWR VPWR sky130_fd_sc_hd__decap_3
XTAP_TAPCELL_ROW_26_559 VGND VPWR sky130_fd_sc_hd__tapvpwrvgnd_1
XFILLER_11_203 VGND VGND VPWR VPWR sky130_fd_sc_hd__decap_3
XFILLER_34_79 VGND VGND VPWR VPWR sky130_fd_sc_hd__decap_3
XFILLER_51_361 VGND VGND VPWR VPWR sky130_fd_sc_hd__fill_1
XFILLER_11_225 VGND VGND VPWR VPWR sky130_fd_sc_hd__decap_3
XFILLER_109_102 VGND VGND VPWR VPWR sky130_fd_sc_hd__decap_3
XFILLER_109_113 VGND VGND VPWR VPWR sky130_fd_sc_hd__decap_3
XFILLER_50_12 VGND VGND VPWR VPWR sky130_fd_sc_hd__decap_3
Xclkload1 clkload1/A VGND VGND VPWR VPWR clkload1/X sky130_fd_sc_hd__clkbuf_16
XFILLER_109_146 VGND VGND VPWR VPWR sky130_fd_sc_hd__decap_3
XFILLER_50_67 VGND VGND VPWR VPWR sky130_fd_sc_hd__decap_3
XFILLER_3_402 VGND VGND VPWR VPWR sky130_fd_sc_hd__decap_3
XFILLER_3_435 VGND VGND VPWR VPWR sky130_fd_sc_hd__decap_3
XFILLER_59_21 VGND VGND VPWR VPWR sky130_fd_sc_hd__decap_3
XFILLER_105_374 VGND VGND VPWR VPWR sky130_fd_sc_hd__decap_3
XFILLER_105_396 VGND VGND VPWR VPWR sky130_fd_sc_hd__decap_3
XFILLER_59_54 VGND VGND VPWR VPWR sky130_fd_sc_hd__fill_2
XFILLER_78_203 VGND VGND VPWR VPWR sky130_fd_sc_hd__decap_3
XFILLER_66_409 VGND VGND VPWR VPWR sky130_fd_sc_hd__decap_3
XFILLER_78_258 VGND VGND VPWR VPWR sky130_fd_sc_hd__fill_1
XFILLER_115_60 VGND VGND VPWR VPWR sky130_fd_sc_hd__decap_3
XFILLER_47_601 VGND VGND VPWR VPWR sky130_fd_sc_hd__decap_3
XFILLER_47_623 VGND VGND VPWR VPWR sky130_fd_sc_hd__decap_3
XFILLER_93_217 VGND VGND VPWR VPWR sky130_fd_sc_hd__decap_3
XFILLER_115_93 VGND VGND VPWR VPWR sky130_fd_sc_hd__decap_3
XFILLER_19_347 VGND VGND VPWR VPWR sky130_fd_sc_hd__fill_2
XFILLER_47_656 VGND VGND VPWR VPWR sky130_fd_sc_hd__decap_3
XFILLER_59_494 VGND VGND VPWR VPWR sky130_fd_sc_hd__decap_3
XTAP_TAPCELL_ROW_70_1093 VGND VPWR sky130_fd_sc_hd__tapvpwrvgnd_1
XFILLER_19_369 VGND VGND VPWR VPWR sky130_fd_sc_hd__decap_3
XFILLER_46_144 VGND VGND VPWR VPWR sky130_fd_sc_hd__decap_3
XFILLER_62_604 VGND VGND VPWR VPWR sky130_fd_sc_hd__decap_3
XFILLER_75_75 VGND VGND VPWR VPWR sky130_fd_sc_hd__fill_1
XTAP_TAPCELL_ROW_109_1557 VGND VPWR sky130_fd_sc_hd__tapvpwrvgnd_1
XFILLER_61_103 VGND VGND VPWR VPWR sky130_fd_sc_hd__decap_3
XFILLER_62_637 VGND VGND VPWR VPWR sky130_fd_sc_hd__decap_3
XFILLER_62_648 VGND VGND VPWR VPWR sky130_fd_sc_hd__decap_3
XFILLER_74_497 VGND VGND VPWR VPWR sky130_fd_sc_hd__decap_3
XFILLER_15_586 VGND VGND VPWR VPWR sky130_fd_sc_hd__decap_3
XFILLER_42_350 VGND VGND VPWR VPWR sky130_fd_sc_hd__decap_3
XFILLER_70_681 VGND VGND VPWR VPWR sky130_fd_sc_hd__decap_3
XFILLER_91_63 VGND VGND VPWR VPWR sky130_fd_sc_hd__decap_3
XFILLER_91_96 VGND VGND VPWR VPWR sky130_fd_sc_hd__decap_3
XTAP_TAPCELL_ROW_53_890 VGND VPWR sky130_fd_sc_hd__tapvpwrvgnd_1
XFILLER_30_589 VGND VGND VPWR VPWR sky130_fd_sc_hd__decap_3
XFILLER_10_280 VGND VGND VPWR VPWR sky130_fd_sc_hd__decap_3
XFILLER_115_105 VGND VGND VPWR VPWR sky130_fd_sc_hd__decap_3
XFILLER_116_606 VGND VGND VPWR VPWR sky130_fd_sc_hd__decap_3
XFILLER_116_617 VGND VGND VPWR VPWR sky130_fd_sc_hd__decap_3
Xhold708 _6823_/Q VGND VGND VPWR VPWR _6823_/D sky130_fd_sc_hd__dlygate4sd3_1
Xhold719 _6928_/Q VGND VGND VPWR VPWR _6928_/D sky130_fd_sc_hd__dlygate4sd3_1
XFILLER_109_691 VGND VGND VPWR VPWR sky130_fd_sc_hd__fill_1
XFILLER_115_116 VGND VGND VPWR VPWR sky130_fd_sc_hd__decap_3
XFILLER_115_149 VGND VGND VPWR VPWR sky130_fd_sc_hd__decap_3
XFILLER_34_3 VGND VGND VPWR VPWR sky130_fd_sc_hd__decap_3
XFILLER_69_214 VGND VGND VPWR VPWR sky130_fd_sc_hd__decap_3
XFILLER_69_225 VGND VGND VPWR VPWR sky130_fd_sc_hd__decap_3
X_5120_ _5120_/A _5120_/B VGND VGND VPWR VPWR _6984_/D sky130_fd_sc_hd__nor2_2
XFILLER_69_269 VGND VGND VPWR VPWR sky130_fd_sc_hd__decap_3
XFILLER_97_567 VGND VGND VPWR VPWR sky130_fd_sc_hd__decap_3
X_5051_ _5073_/A _5050_/X _5054_/A VGND VGND VPWR VPWR _5051_/X sky130_fd_sc_hd__a21o_2
XFILLER_111_388 VGND VGND VPWR VPWR sky130_fd_sc_hd__decap_3
XFILLER_38_623 VGND VGND VPWR VPWR sky130_fd_sc_hd__decap_3
XFILLER_1_50 VGND VGND VPWR VPWR sky130_fd_sc_hd__decap_3
XFILLER_38_634 VGND VGND VPWR VPWR sky130_fd_sc_hd__fill_2
XFILLER_38_645 VGND VGND VPWR VPWR sky130_fd_sc_hd__decap_3
XTAP_TAPCELL_ROW_88_1310 VGND VPWR sky130_fd_sc_hd__tapvpwrvgnd_1
XFILLER_1_72 VGND VGND VPWR VPWR sky130_fd_sc_hd__decap_3
XFILLER_37_155 VGND VGND VPWR VPWR sky130_fd_sc_hd__fill_2
XFILLER_37_166 VGND VGND VPWR VPWR sky130_fd_sc_hd__fill_2
XFILLER_38_678 VGND VGND VPWR VPWR sky130_fd_sc_hd__decap_3
XFILLER_53_604 VGND VGND VPWR VPWR sky130_fd_sc_hd__decap_3
XFILLER_92_250 VGND VGND VPWR VPWR sky130_fd_sc_hd__fill_2
XFILLER_111_29 VGND VGND VPWR VPWR sky130_fd_sc_hd__decap_3
XFILLER_25_328 VGND VGND VPWR VPWR sky130_fd_sc_hd__decap_3
XFILLER_53_626 VGND VGND VPWR VPWR sky130_fd_sc_hd__decap_3
XFILLER_65_486 VGND VGND VPWR VPWR sky130_fd_sc_hd__decap_3
XPHY_EDGE_ROW_9_Left_126 VGND VGND VPWR VPWR sky130_fd_sc_hd__decap_3
XFILLER_52_147 VGND VGND VPWR VPWR sky130_fd_sc_hd__fill_1
XFILLER_53_659 VGND VGND VPWR VPWR sky130_fd_sc_hd__decap_3
XFILLER_40_309 VGND VGND VPWR VPWR sky130_fd_sc_hd__decap_3
X_4904_ _4903_/A _4904_/B VGND VGND VPWR VPWR _4904_/X sky130_fd_sc_hd__and2b_2
XTAP_TAPCELL_ROW_23_529 VGND VPWR sky130_fd_sc_hd__tapvpwrvgnd_1
X_4835_ _4467_/B _3709_/X _4832_/X _4834_/Y VGND VGND VPWR VPWR _4835_/X sky130_fd_sc_hd__a31o_2
X_4766_ _4766_/A VGND VGND VPWR VPWR _4766_/Y sky130_fd_sc_hd__inv_2
X_6505_ _6535_/A VGND VGND VPWR VPWR _6505_/Y sky130_fd_sc_hd__inv_2
XFILLER_107_617 VGND VGND VPWR VPWR sky130_fd_sc_hd__decap_3
XFILLER_20_15 VGND VGND VPWR VPWR sky130_fd_sc_hd__decap_3
X_4697_ _4697_/A _6984_/Q _5670_/B VGND VGND VPWR VPWR _5120_/A sky130_fd_sc_hd__and3_2
XFILLER_105_9 VGND VGND VPWR VPWR sky130_fd_sc_hd__decap_3
XFILLER_20_37 VGND VGND VPWR VPWR sky130_fd_sc_hd__decap_3
X_6436_ _6570_/A VGND VGND VPWR VPWR _6436_/Y sky130_fd_sc_hd__inv_2
XFILLER_115_650 VGND VGND VPWR VPWR sky130_fd_sc_hd__decap_3
X_6367_ _6567_/A VGND VGND VPWR VPWR _6367_/Y sky130_fd_sc_hd__inv_2
X_3579_ _7220_/Q _4331_/A2 _3977_/S _7188_/Q VGND VGND VPWR VPWR _3579_/X sky130_fd_sc_hd__a22o_2
XFILLER_0_405 VGND VGND VPWR VPWR sky130_fd_sc_hd__fill_1
XFILLER_0_427 VGND VGND VPWR VPWR sky130_fd_sc_hd__decap_3
XFILLER_114_171 VGND VGND VPWR VPWR sky130_fd_sc_hd__decap_3
XFILLER_0_449 VGND VGND VPWR VPWR sky130_fd_sc_hd__decap_3
XFILLER_102_333 VGND VGND VPWR VPWR sky130_fd_sc_hd__decap_3
X_6298_ _6611_/A VGND VGND VPWR VPWR _6298_/Y sky130_fd_sc_hd__inv_2
XFILLER_29_57 VGND VGND VPWR VPWR sky130_fd_sc_hd__decap_3
XFILLER_88_589 VGND VGND VPWR VPWR sky130_fd_sc_hd__fill_2
X_5249_ _5249_/A0 _4878_/X _5262_/S VGND VGND VPWR VPWR _7205_/D sky130_fd_sc_hd__mux2_2
XFILLER_28_122 VGND VGND VPWR VPWR sky130_fd_sc_hd__decap_3
XFILLER_29_623 VGND VGND VPWR VPWR sky130_fd_sc_hd__decap_3
XFILLER_75_239 VGND VGND VPWR VPWR sky130_fd_sc_hd__decap_3
XFILLER_28_144 VGND VGND VPWR VPWR sky130_fd_sc_hd__decap_3
XFILLER_45_12 VGND VGND VPWR VPWR sky130_fd_sc_hd__decap_3
XFILLER_56_464 VGND VGND VPWR VPWR sky130_fd_sc_hd__decap_3
XTAP_TAPCELL_ROW_3_287 VGND VPWR sky130_fd_sc_hd__tapvpwrvgnd_1
XFILLER_56_486 VGND VGND VPWR VPWR sky130_fd_sc_hd__fill_1
XFILLER_83_294 VGND VGND VPWR VPWR sky130_fd_sc_hd__fill_2
XFILLER_45_89 VGND VGND VPWR VPWR sky130_fd_sc_hd__decap_3
XFILLER_71_467 VGND VGND VPWR VPWR sky130_fd_sc_hd__decap_3
XFILLER_43_169 VGND VGND VPWR VPWR sky130_fd_sc_hd__fill_1
XFILLER_52_681 VGND VGND VPWR VPWR sky130_fd_sc_hd__decap_3
XFILLER_101_62 VGND VGND VPWR VPWR sky130_fd_sc_hd__decap_3
XFILLER_24_394 VGND VGND VPWR VPWR sky130_fd_sc_hd__fill_2
XFILLER_51_191 VGND VGND VPWR VPWR sky130_fd_sc_hd__decap_3
XTAP_TAPCELL_ROW_104_1498 VGND VPWR sky130_fd_sc_hd__tapvpwrvgnd_1
XFILLER_101_95 VGND VGND VPWR VPWR sky130_fd_sc_hd__decap_3
XFILLER_12_567 VGND VGND VPWR VPWR sky130_fd_sc_hd__decap_3
XFILLER_12_589 VGND VGND VPWR VPWR sky130_fd_sc_hd__fill_2
XFILLER_61_44 VGND VGND VPWR VPWR sky130_fd_sc_hd__decap_3
XFILLER_61_88 VGND VGND VPWR VPWR sky130_fd_sc_hd__decap_3
XFILLER_113_609 VGND VGND VPWR VPWR sky130_fd_sc_hd__decap_3
XFILLER_98_309 VGND VGND VPWR VPWR sky130_fd_sc_hd__fill_2
XFILLER_106_672 VGND VGND VPWR VPWR sky130_fd_sc_hd__decap_3
XTAP_TAPCELL_ROW_72_1111 VGND VPWR sky130_fd_sc_hd__tapvpwrvgnd_1
XFILLER_105_193 VGND VGND VPWR VPWR sky130_fd_sc_hd__decap_3
XFILLER_79_567 VGND VGND VPWR VPWR sky130_fd_sc_hd__decap_3
XFILLER_20_9 VGND VGND VPWR VPWR sky130_fd_sc_hd__decap_3
XFILLER_94_526 VGND VGND VPWR VPWR sky130_fd_sc_hd__decap_3
XFILLER_19_122 VGND VGND VPWR VPWR sky130_fd_sc_hd__decap_3
XFILLER_59_291 VGND VGND VPWR VPWR sky130_fd_sc_hd__decap_3
XFILLER_66_228 VGND VGND VPWR VPWR sky130_fd_sc_hd__decap_3
XFILLER_86_85 VGND VGND VPWR VPWR sky130_fd_sc_hd__decap_3
XFILLER_34_103 VGND VGND VPWR VPWR sky130_fd_sc_hd__decap_3
XFILLER_34_136 VGND VGND VPWR VPWR sky130_fd_sc_hd__decap_3
XFILLER_34_147 VGND VGND VPWR VPWR sky130_fd_sc_hd__decap_3
XFILLER_34_158 VGND VGND VPWR VPWR sky130_fd_sc_hd__decap_3
XFILLER_62_456 VGND VGND VPWR VPWR sky130_fd_sc_hd__decap_3
XFILLER_50_618 VGND VGND VPWR VPWR sky130_fd_sc_hd__decap_3
XTAP_TAPCELL_ROW_83_1251 VGND VPWR sky130_fd_sc_hd__tapvpwrvgnd_1
XFILLER_15_383 VGND VGND VPWR VPWR sky130_fd_sc_hd__fill_1
XFILLER_42_191 VGND VGND VPWR VPWR sky130_fd_sc_hd__decap_3
X_4620_ _4620_/A _5003_/A _4620_/C _5032_/A VGND VGND VPWR VPWR _4624_/B sky130_fd_sc_hd__and4_4
XFILLER_116_414 VGND VGND VPWR VPWR sky130_fd_sc_hd__decap_3
XFILLER_7_593 VGND VGND VPWR VPWR sky130_fd_sc_hd__decap_3
X_7270_ _7334_/CLK _7270_/D _6550_/Y VGND VGND VPWR VPWR _7270_/Q sky130_fd_sc_hd__dfrtp_2
X_4482_ _4482_/A0 _7306_/Q _4482_/S VGND VGND VPWR VPWR _4482_/X sky130_fd_sc_hd__mux2_2
X_3502_ _3502_/A _3502_/B _3485_/C VGND VGND VPWR VPWR _3502_/X sky130_fd_sc_hd__or3b_2
XFILLER_103_119 VGND VGND VPWR VPWR sky130_fd_sc_hd__decap_3
XFILLER_106_18 VGND VGND VPWR VPWR sky130_fd_sc_hd__decap_3
XTAP_TAPCELL_ROW_94_1380 VGND VPWR sky130_fd_sc_hd__tapvpwrvgnd_1
XFILLER_106_29 VGND VGND VPWR VPWR sky130_fd_sc_hd__decap_3
XFILLER_112_631 VGND VGND VPWR VPWR sky130_fd_sc_hd__decap_3
X_5103_ _5146_/B1 _5047_/Y _5099_/X _5102_/X VGND VGND VPWR VPWR _5651_/A sky130_fd_sc_hd__a31oi_2
X_3364_ _3362_/X _5294_/B _3371_/A VGND VGND VPWR VPWR _3399_/B sky130_fd_sc_hd__a21boi_2
XFILLER_111_152 VGND VGND VPWR VPWR sky130_fd_sc_hd__decap_3
XFILLER_112_675 VGND VGND VPWR VPWR sky130_fd_sc_hd__decap_3
XFILLER_97_375 VGND VGND VPWR VPWR sky130_fd_sc_hd__decap_3
Xhold1205 _7165_/Q VGND VGND VPWR VPWR _5331_/A0 sky130_fd_sc_hd__dlygate4sd3_1
Xhold1216 _7317_/Q VGND VGND VPWR VPWR _4524_/A0 sky130_fd_sc_hd__dlygate4sd3_1
XFILLER_111_196 VGND VGND VPWR VPWR sky130_fd_sc_hd__decap_3
XFILLER_57_239 VGND VGND VPWR VPWR sky130_fd_sc_hd__decap_3
Xhold1227 _7124_/Q VGND VGND VPWR VPWR _5419_/A0 sky130_fd_sc_hd__dlygate4sd3_1
X_5034_ _5146_/B1 _5031_/X _5032_/Y _4969_/B _5033_/X VGND VGND VPWR VPWR _5658_/B
+ sky130_fd_sc_hd__a221o_2
XTAP_TAPCELL_ROW_56_919 VGND VPWR sky130_fd_sc_hd__tapvpwrvgnd_1
XFILLER_38_475 VGND VGND VPWR VPWR sky130_fd_sc_hd__fill_1
XFILLER_53_423 VGND VGND VPWR VPWR sky130_fd_sc_hd__fill_2
XTAP_TAPCELL_ROW_0_235 VGND VPWR sky130_fd_sc_hd__tapvpwrvgnd_1
XFILLER_25_125 VGND VGND VPWR VPWR sky130_fd_sc_hd__fill_2
XFILLER_53_445 VGND VGND VPWR VPWR sky130_fd_sc_hd__decap_3
X_6985_ _7364_/CLK _6985_/D _6265_/Y VGND VGND VPWR VPWR _6985_/Q sky130_fd_sc_hd__dfrtp_2
XTAP_TAPCELL_ROW_0_257 VGND VPWR sky130_fd_sc_hd__tapvpwrvgnd_1
XTAP_TAPCELL_ROW_0_246 VGND VPWR sky130_fd_sc_hd__tapvpwrvgnd_1
XFILLER_15_15 VGND VGND VPWR VPWR sky130_fd_sc_hd__decap_3
XFILLER_15_48 VGND VGND VPWR VPWR sky130_fd_sc_hd__decap_3
XFILLER_25_169 VGND VGND VPWR VPWR sky130_fd_sc_hd__fill_2
XFILLER_80_253 VGND VGND VPWR VPWR sky130_fd_sc_hd__fill_2
XTAP_TAPCELL_ROW_36_687 VGND VPWR sky130_fd_sc_hd__tapvpwrvgnd_1
XFILLER_40_128 VGND VGND VPWR VPWR sky130_fd_sc_hd__decap_3
X_4818_ _7002_/Q _4834_/A VGND VGND VPWR VPWR _4818_/Y sky130_fd_sc_hd__nand2_2
XFILLER_107_403 VGND VGND VPWR VPWR sky130_fd_sc_hd__fill_1
X_4749_ _7006_/Q _4749_/B VGND VGND VPWR VPWR _4750_/C sky130_fd_sc_hd__nor2_2
XFILLER_107_436 VGND VGND VPWR VPWR sky130_fd_sc_hd__decap_3
XFILLER_103_6 VGND VGND VPWR VPWR sky130_fd_sc_hd__decap_3
XFILLER_107_469 VGND VGND VPWR VPWR sky130_fd_sc_hd__decap_3
X_6419_ _6578_/A VGND VGND VPWR VPWR _6419_/Y sky130_fd_sc_hd__inv_2
XFILLER_0_202 VGND VGND VPWR VPWR sky130_fd_sc_hd__fill_1
X_7399_ _7403_/CLK _7399_/D _6679_/Y VGND VGND VPWR VPWR _7399_/Q sky130_fd_sc_hd__dfrtp_2
XFILLER_103_620 VGND VGND VPWR VPWR sky130_fd_sc_hd__decap_3
XFILLER_103_653 VGND VGND VPWR VPWR sky130_fd_sc_hd__decap_3
XFILLER_115_480 VGND VGND VPWR VPWR sky130_fd_sc_hd__fill_2
XFILLER_88_320 VGND VGND VPWR VPWR sky130_fd_sc_hd__decap_3
XTAP_TAPCELL_ROW_8_346 VGND VPWR sky130_fd_sc_hd__tapvpwrvgnd_1
XFILLER_0_279 VGND VGND VPWR VPWR sky130_fd_sc_hd__fill_1
XFILLER_102_141 VGND VGND VPWR VPWR sky130_fd_sc_hd__decap_3
XFILLER_48_206 VGND VGND VPWR VPWR sky130_fd_sc_hd__decap_3
XFILLER_88_386 VGND VGND VPWR VPWR sky130_fd_sc_hd__decap_3
XFILLER_29_420 VGND VGND VPWR VPWR sky130_fd_sc_hd__decap_3
XFILLER_17_604 VGND VGND VPWR VPWR sky130_fd_sc_hd__decap_3
XFILLER_56_66 VGND VGND VPWR VPWR sky130_fd_sc_hd__decap_3
XFILLER_56_283 VGND VGND VPWR VPWR sky130_fd_sc_hd__decap_3
XTAP_TAPCELL_ROW_106_1527 VGND VPWR sky130_fd_sc_hd__tapvpwrvgnd_1
XFILLER_112_50 VGND VGND VPWR VPWR sky130_fd_sc_hd__decap_3
XFILLER_16_125 VGND VGND VPWR VPWR sky130_fd_sc_hd__decap_3
XFILLER_71_220 VGND VGND VPWR VPWR sky130_fd_sc_hd__decap_3
XFILLER_71_242 VGND VGND VPWR VPWR sky130_fd_sc_hd__fill_2
XFILLER_112_83 VGND VGND VPWR VPWR sky130_fd_sc_hd__fill_1
XFILLER_112_94 VGND VGND VPWR VPWR sky130_fd_sc_hd__decap_3
XFILLER_31_106 VGND VGND VPWR VPWR sky130_fd_sc_hd__decap_3
XFILLER_72_21 VGND VGND VPWR VPWR sky130_fd_sc_hd__decap_3
XFILLER_31_128 VGND VGND VPWR VPWR sky130_fd_sc_hd__decap_3
XFILLER_72_76 VGND VGND VPWR VPWR sky130_fd_sc_hd__decap_3
XFILLER_12_331 VGND VGND VPWR VPWR sky130_fd_sc_hd__decap_3
XFILLER_24_191 VGND VGND VPWR VPWR sky130_fd_sc_hd__decap_3
XFILLER_8_302 VGND VGND VPWR VPWR sky130_fd_sc_hd__decap_3
XFILLER_40_673 VGND VGND VPWR VPWR sky130_fd_sc_hd__decap_3
XFILLER_8_368 VGND VGND VPWR VPWR sky130_fd_sc_hd__decap_3
XFILLER_21_91 VGND VGND VPWR VPWR sky130_fd_sc_hd__fill_1
XFILLER_4_530 VGND VGND VPWR VPWR sky130_fd_sc_hd__fill_2
XFILLER_113_406 VGND VGND VPWR VPWR sky130_fd_sc_hd__decap_3
XFILLER_99_629 VGND VGND VPWR VPWR sky130_fd_sc_hd__decap_3
XFILLER_98_128 VGND VGND VPWR VPWR sky130_fd_sc_hd__fill_1
XFILLER_39_206 VGND VGND VPWR VPWR sky130_fd_sc_hd__decap_3
XFILLER_94_301 VGND VGND VPWR VPWR sky130_fd_sc_hd__decap_3
XFILLER_39_228 VGND VGND VPWR VPWR sky130_fd_sc_hd__decap_3
XFILLER_67_548 VGND VGND VPWR VPWR sky130_fd_sc_hd__decap_3
XFILLER_94_323 VGND VGND VPWR VPWR sky130_fd_sc_hd__decap_3
XFILLER_54_209 VGND VGND VPWR VPWR sky130_fd_sc_hd__decap_3
XFILLER_94_356 VGND VGND VPWR VPWR sky130_fd_sc_hd__decap_3
XFILLER_75_581 VGND VGND VPWR VPWR sky130_fd_sc_hd__decap_3
XFILLER_35_445 VGND VGND VPWR VPWR sky130_fd_sc_hd__decap_3
XFILLER_62_220 VGND VGND VPWR VPWR sky130_fd_sc_hd__decap_3
XFILLER_90_551 VGND VGND VPWR VPWR sky130_fd_sc_hd__fill_2
XFILLER_50_404 VGND VGND VPWR VPWR sky130_fd_sc_hd__decap_3
XFILLER_62_253 VGND VGND VPWR VPWR sky130_fd_sc_hd__decap_3
X_6770_ _6944_/CLK _6770_/D VGND VGND VPWR VPWR _6770_/Q sky130_fd_sc_hd__dfxtp_2
XFILLER_15_180 VGND VGND VPWR VPWR sky130_fd_sc_hd__decap_3
XFILLER_16_681 VGND VGND VPWR VPWR sky130_fd_sc_hd__decap_3
X_5721_ _7366_/Q hold953/X _5721_/S VGND VGND VPWR VPWR _6710_/D sky130_fd_sc_hd__mux2_2
XTAP_TAPCELL_ROW_33_646 VGND VPWR sky130_fd_sc_hd__tapvpwrvgnd_1
XFILLER_31_640 VGND VGND VPWR VPWR sky130_fd_sc_hd__decap_3
XFILLER_31_651 VGND VGND VPWR VPWR sky130_fd_sc_hd__fill_2
XTAP_TAPCELL_ROW_61_988 VGND VPWR sky130_fd_sc_hd__tapvpwrvgnd_1
XPHY_EDGE_ROW_99_Left_216 VGND VGND VPWR VPWR sky130_fd_sc_hd__decap_3
XFILLER_31_673 VGND VGND VPWR VPWR sky130_fd_sc_hd__fill_2
X_5652_ _5664_/A VGND VGND VPWR VPWR _5652_/Y sky130_fd_sc_hd__inv_2
XFILLER_30_183 VGND VGND VPWR VPWR sky130_fd_sc_hd__decap_3
X_5583_ _5583_/A0 _5094_/X _5595_/B VGND VGND VPWR VPWR _7037_/D sky130_fd_sc_hd__mux2_2
X_4603_ hold998/X _4577_/B _3487_/X VGND VGND VPWR VPWR _7279_/D sky130_fd_sc_hd__a21o_2
XFILLER_116_200 VGND VGND VPWR VPWR sky130_fd_sc_hd__decap_3
XFILLER_116_222 VGND VGND VPWR VPWR sky130_fd_sc_hd__fill_2
XFILLER_7_60 VGND VGND VPWR VPWR sky130_fd_sc_hd__decap_3
X_7322_ _7352_/CLK _7322_/D _6602_/Y VGND VGND VPWR VPWR _7322_/Q sky130_fd_sc_hd__dfrtp_2
X_4534_ _4534_/A0 _7280_/Q _4534_/S VGND VGND VPWR VPWR _7312_/D sky130_fd_sc_hd__mux2_2
XFILLER_7_93 VGND VGND VPWR VPWR sky130_fd_sc_hd__decap_3
XFILLER_116_277 VGND VGND VPWR VPWR sky130_fd_sc_hd__decap_3
X_7253_ clkload6/A _7253_/D _6533_/Y VGND VGND VPWR VPWR _7253_/Q sky130_fd_sc_hd__dfrtp_2
X_4465_ _5655_/B _5655_/C VGND VGND VPWR VPWR _5650_/A sky130_fd_sc_hd__nor2_2
X_7184_ _7387_/CLK _7184_/D _6464_/Y VGND VGND VPWR VPWR _7184_/Q sky130_fd_sc_hd__dfrtp_2
X_4396_ _4396_/A _4444_/B VGND VGND VPWR VPWR _4648_/A sky130_fd_sc_hd__nor2_2
XFILLER_98_651 VGND VGND VPWR VPWR sky130_fd_sc_hd__decap_3
X_3347_ _5640_/B _3347_/B VGND VGND VPWR VPWR _3420_/A sky130_fd_sc_hd__or2_2
XTAP_TAPCELL_ROW_5_316 VGND VPWR sky130_fd_sc_hd__tapvpwrvgnd_1
XFILLER_100_623 VGND VGND VPWR VPWR sky130_fd_sc_hd__decap_3
XFILLER_100_645 VGND VGND VPWR VPWR sky130_fd_sc_hd__decap_3
XFILLER_112_483 VGND VGND VPWR VPWR sky130_fd_sc_hd__decap_3
XFILLER_85_323 VGND VGND VPWR VPWR sky130_fd_sc_hd__fill_2
XFILLER_97_172 VGND VGND VPWR VPWR sky130_fd_sc_hd__decap_3
Xhold1002 _7015_/Q VGND VGND VPWR VPWR _5626_/A sky130_fd_sc_hd__dlygate4sd3_1
Xhold1013 _7202_/Q VGND VGND VPWR VPWR _5256_/A0 sky130_fd_sc_hd__dlygate4sd3_1
Xhold1024 _7185_/Q VGND VGND VPWR VPWR _5288_/A0 sky130_fd_sc_hd__dlygate4sd3_1
XFILLER_100_678 VGND VGND VPWR VPWR sky130_fd_sc_hd__decap_3
XFILLER_45_209 VGND VGND VPWR VPWR sky130_fd_sc_hd__fill_1
XFILLER_85_367 VGND VGND VPWR VPWR sky130_fd_sc_hd__decap_3
Xhold1035 _7229_/Q VGND VGND VPWR VPWR _5198_/A sky130_fd_sc_hd__dlygate4sd3_1
Xhold1046 _7231_/Q VGND VGND VPWR VPWR _5194_/A sky130_fd_sc_hd__dlygate4sd3_1
Xhold1057 _7258_/Q VGND VGND VPWR VPWR _5063_/A0 sky130_fd_sc_hd__dlygate4sd3_1
X_5017_ _5018_/A _5017_/B VGND VGND VPWR VPWR _5017_/Y sky130_fd_sc_hd__xnor2_2
XFILLER_38_250 VGND VGND VPWR VPWR sky130_fd_sc_hd__fill_2
XFILLER_38_272 VGND VGND VPWR VPWR sky130_fd_sc_hd__decap_3
XFILLER_85_389 VGND VGND VPWR VPWR sky130_fd_sc_hd__decap_3
Xhold1068 _7233_/Q VGND VGND VPWR VPWR _5190_/A sky130_fd_sc_hd__dlygate4sd3_1
Xhold1079 _7341_/Q VGND VGND VPWR VPWR _4476_/A0 sky130_fd_sc_hd__dlygate4sd3_1
XFILLER_26_36 VGND VGND VPWR VPWR sky130_fd_sc_hd__fill_2
XFILLER_53_231 VGND VGND VPWR VPWR sky130_fd_sc_hd__decap_3
XFILLER_66_592 VGND VGND VPWR VPWR sky130_fd_sc_hd__decap_3
XFILLER_41_415 VGND VGND VPWR VPWR sky130_fd_sc_hd__decap_3
XFILLER_53_264 VGND VGND VPWR VPWR sky130_fd_sc_hd__decap_3
XFILLER_81_573 VGND VGND VPWR VPWR sky130_fd_sc_hd__fill_1
XFILLER_81_595 VGND VGND VPWR VPWR sky130_fd_sc_hd__decap_3
X_6968_ _6971_/CLK _6968_/D VGND VGND VPWR VPWR _6968_/Q sky130_fd_sc_hd__dfxtp_2
XFILLER_42_24 VGND VGND VPWR VPWR sky130_fd_sc_hd__decap_3
X_6899_ _6946_/CLK _6899_/D VGND VGND VPWR VPWR _6899_/Q sky130_fd_sc_hd__dfxtp_2
XFILLER_42_46 VGND VGND VPWR VPWR sky130_fd_sc_hd__fill_2
XTAP_TAPCELL_ROW_101_1468 VGND VPWR sky130_fd_sc_hd__tapvpwrvgnd_1
XFILLER_5_316 VGND VGND VPWR VPWR sky130_fd_sc_hd__decap_3
XFILLER_107_50 VGND VGND VPWR VPWR sky130_fd_sc_hd__decap_3
XFILLER_3_18 VGND VGND VPWR VPWR sky130_fd_sc_hd__decap_3
Xhold880 _7090_/Q VGND VGND VPWR VPWR _7090_/D sky130_fd_sc_hd__dlygate4sd3_1
Xhold891 _7067_/Q VGND VGND VPWR VPWR _7067_/D sky130_fd_sc_hd__dlygate4sd3_1
XFILLER_107_72 VGND VGND VPWR VPWR sky130_fd_sc_hd__decap_3
XFILLER_67_21 VGND VGND VPWR VPWR sky130_fd_sc_hd__decap_3
XFILLER_89_662 VGND VGND VPWR VPWR sky130_fd_sc_hd__decap_3
XFILLER_89_673 VGND VGND VPWR VPWR sky130_fd_sc_hd__decap_3
XFILLER_103_483 VGND VGND VPWR VPWR sky130_fd_sc_hd__decap_3
XFILLER_1_588 VGND VGND VPWR VPWR sky130_fd_sc_hd__decap_3
XFILLER_67_54 VGND VGND VPWR VPWR sky130_fd_sc_hd__fill_2
XTAP_TAPCELL_ROW_112_1597 VGND VPWR sky130_fd_sc_hd__tapvpwrvgnd_1
XFILLER_49_559 VGND VGND VPWR VPWR sky130_fd_sc_hd__fill_1
XFILLER_29_261 VGND VGND VPWR VPWR sky130_fd_sc_hd__decap_3
XFILLER_36_209 VGND VGND VPWR VPWR sky130_fd_sc_hd__decap_3
XFILLER_57_570 VGND VGND VPWR VPWR sky130_fd_sc_hd__decap_3
XFILLER_64_529 VGND VGND VPWR VPWR sky130_fd_sc_hd__decap_3
XFILLER_76_378 VGND VGND VPWR VPWR sky130_fd_sc_hd__decap_3
XFILLER_91_326 VGND VGND VPWR VPWR sky130_fd_sc_hd__fill_2
XFILLER_44_231 VGND VGND VPWR VPWR sky130_fd_sc_hd__decap_3
XFILLER_83_53 VGND VGND VPWR VPWR sky130_fd_sc_hd__decap_3
XFILLER_91_337 VGND VGND VPWR VPWR sky130_fd_sc_hd__fill_1
XFILLER_32_404 VGND VGND VPWR VPWR sky130_fd_sc_hd__decap_3
XFILLER_44_253 VGND VGND VPWR VPWR sky130_fd_sc_hd__fill_2
XFILLER_72_573 VGND VGND VPWR VPWR sky130_fd_sc_hd__decap_3
XTAP_TAPCELL_ROW_67_1054 VGND VPWR sky130_fd_sc_hd__tapvpwrvgnd_1
XFILLER_16_80 VGND VGND VPWR VPWR sky130_fd_sc_hd__decap_3
XFILLER_72_584 VGND VGND VPWR VPWR sky130_fd_sc_hd__decap_3
XTAP_TAPCELL_ROW_80_1210 VGND VPWR sky130_fd_sc_hd__tapvpwrvgnd_1
XFILLER_13_662 VGND VGND VPWR VPWR sky130_fd_sc_hd__fill_2
XFILLER_13_673 VGND VGND VPWR VPWR sky130_fd_sc_hd__decap_3
XFILLER_8_121 VGND VGND VPWR VPWR sky130_fd_sc_hd__decap_3
XTAP_TAPCELL_ROW_30_616 VGND VPWR sky130_fd_sc_hd__tapvpwrvgnd_1
XFILLER_12_183 VGND VGND VPWR VPWR sky130_fd_sc_hd__decap_3
XFILLER_9_666 VGND VGND VPWR VPWR sky130_fd_sc_hd__decap_3
XFILLER_66_6 VGND VGND VPWR VPWR sky130_fd_sc_hd__decap_3
XFILLER_8_165 VGND VGND VPWR VPWR sky130_fd_sc_hd__decap_3
XFILLER_8_187 VGND VGND VPWR VPWR sky130_fd_sc_hd__decap_3
XFILLER_9_688 VGND VGND VPWR VPWR sky130_fd_sc_hd__decap_3
XTAP_TAPCELL_ROW_10_373 VGND VPWR sky130_fd_sc_hd__tapvpwrvgnd_1
XFILLER_113_214 VGND VGND VPWR VPWR sky130_fd_sc_hd__decap_3
XTAP_TAPCELL_ROW_78_1183 VGND VPWR sky130_fd_sc_hd__tapvpwrvgnd_1
XFILLER_113_225 VGND VGND VPWR VPWR sky130_fd_sc_hd__decap_3
X_4250_ _7101_/Q _4250_/A2 _3409_/X _7165_/Q VGND VGND VPWR VPWR _4250_/X sky130_fd_sc_hd__a22o_2
XFILLER_113_258 VGND VGND VPWR VPWR sky130_fd_sc_hd__decap_3
XFILLER_86_109 VGND VGND VPWR VPWR sky130_fd_sc_hd__fill_2
X_4181_ _7200_/Q _4268_/A2 _4261_/A2 _7392_/Q VGND VGND VPWR VPWR _4181_/X sky130_fd_sc_hd__a22o_2
XFILLER_79_172 VGND VGND VPWR VPWR sky130_fd_sc_hd__decap_3
XFILLER_95_632 VGND VGND VPWR VPWR sky130_fd_sc_hd__decap_3
XFILLER_94_120 VGND VGND VPWR VPWR sky130_fd_sc_hd__decap_3
XFILLER_95_665 VGND VGND VPWR VPWR sky130_fd_sc_hd__decap_3
XFILLER_95_676 VGND VGND VPWR VPWR sky130_fd_sc_hd__decap_3
XFILLER_55_518 VGND VGND VPWR VPWR sky130_fd_sc_hd__fill_1
XFILLER_67_389 VGND VGND VPWR VPWR sky130_fd_sc_hd__decap_3
XFILLER_82_315 VGND VGND VPWR VPWR sky130_fd_sc_hd__decap_3
XTAP_TAPCELL_ROW_38_705 VGND VPWR sky130_fd_sc_hd__tapvpwrvgnd_1
XFILLER_35_220 VGND VGND VPWR VPWR sky130_fd_sc_hd__decap_3
XFILLER_35_231 VGND VGND VPWR VPWR sky130_fd_sc_hd__decap_3
XFILLER_82_359 VGND VGND VPWR VPWR sky130_fd_sc_hd__decap_3
XFILLER_94_197 VGND VGND VPWR VPWR sky130_fd_sc_hd__decap_3
XFILLER_35_264 VGND VGND VPWR VPWR sky130_fd_sc_hd__decap_3
X_6822_ _6970_/CLK _6822_/D VGND VGND VPWR VPWR _6822_/Q sky130_fd_sc_hd__dfxtp_2
XFILLER_63_595 VGND VGND VPWR VPWR sky130_fd_sc_hd__decap_3
XTAP_TAPCELL_ROW_18_473 VGND VPWR sky130_fd_sc_hd__tapvpwrvgnd_1
XTAP_TAPCELL_ROW_18_462 VGND VPWR sky130_fd_sc_hd__tapvpwrvgnd_1
X_6753_ _6972_/CLK _6753_/D VGND VGND VPWR VPWR _6753_/Q sky130_fd_sc_hd__dfxtp_2
XFILLER_10_109 VGND VGND VPWR VPWR sky130_fd_sc_hd__decap_3
XFILLER_50_289 VGND VGND VPWR VPWR sky130_fd_sc_hd__decap_3
X_6684_ _6684_/A VGND VGND VPWR VPWR _6684_/Y sky130_fd_sc_hd__inv_2
X_3896_ _3880_/X _3885_/X _3895_/X _3896_/B1 VGND VGND VPWR VPWR _3896_/Y sky130_fd_sc_hd__o31ai_2
XFILLER_12_27 VGND VGND VPWR VPWR sky130_fd_sc_hd__fill_1
XFILLER_12_38 VGND VGND VPWR VPWR sky130_fd_sc_hd__decap_3
X_5566_ hold988/X _5570_/A2 _4860_/Y VGND VGND VPWR VPWR _7051_/D sky130_fd_sc_hd__o21a_2
X_7305_ _7337_/CLK _7305_/D _6585_/Y VGND VGND VPWR VPWR _7305_/Q sky130_fd_sc_hd__dfrtp_2
X_4517_ _4517_/A0 _7289_/Q _4517_/S VGND VGND VPWR VPWR _7321_/D sky130_fd_sc_hd__mux2_2
XFILLER_104_225 VGND VGND VPWR VPWR sky130_fd_sc_hd__decap_3
XFILLER_104_247 VGND VGND VPWR VPWR sky130_fd_sc_hd__decap_3
X_7236_ _7397_/CLK _7236_/D _6516_/Y VGND VGND VPWR VPWR _7236_/Q sky130_fd_sc_hd__dfrtp_2
X_4448_ _4444_/X _4447_/Y _4413_/A VGND VGND VPWR VPWR _4448_/X sky130_fd_sc_hd__o21a_2
XFILLER_58_312 VGND VGND VPWR VPWR sky130_fd_sc_hd__decap_3
XFILLER_86_621 VGND VGND VPWR VPWR sky130_fd_sc_hd__decap_3
X_7167_ _7266_/CLK _7167_/D _6447_/Y VGND VGND VPWR VPWR _7167_/Q sky130_fd_sc_hd__dfrtp_2
X_4379_ _4938_/B _4379_/B VGND VGND VPWR VPWR _4937_/A sky130_fd_sc_hd__or2_2
XFILLER_98_470 VGND VGND VPWR VPWR sky130_fd_sc_hd__decap_3
XFILLER_112_291 VGND VGND VPWR VPWR sky130_fd_sc_hd__decap_3
XFILLER_37_24 VGND VGND VPWR VPWR sky130_fd_sc_hd__decap_3
XFILLER_58_345 VGND VGND VPWR VPWR sky130_fd_sc_hd__decap_3
XFILLER_85_131 VGND VGND VPWR VPWR sky130_fd_sc_hd__decap_3
XFILLER_86_654 VGND VGND VPWR VPWR sky130_fd_sc_hd__decap_3
X_7098_ clkload8/A _7098_/D _6378_/Y VGND VGND VPWR VPWR _7098_/Q sky130_fd_sc_hd__dfrtp_2
XFILLER_100_475 VGND VGND VPWR VPWR sky130_fd_sc_hd__fill_1
XFILLER_100_486 VGND VGND VPWR VPWR sky130_fd_sc_hd__decap_3
XFILLER_37_57 VGND VGND VPWR VPWR sky130_fd_sc_hd__decap_3
XFILLER_85_175 VGND VGND VPWR VPWR sky130_fd_sc_hd__decap_3
XFILLER_86_687 VGND VGND VPWR VPWR sky130_fd_sc_hd__decap_3
XFILLER_37_79 VGND VGND VPWR VPWR sky130_fd_sc_hd__decap_3
XFILLER_39_592 VGND VGND VPWR VPWR sky130_fd_sc_hd__decap_3
XFILLER_73_337 VGND VGND VPWR VPWR sky130_fd_sc_hd__decap_3
XFILLER_41_212 VGND VGND VPWR VPWR sky130_fd_sc_hd__fill_1
XFILLER_41_223 VGND VGND VPWR VPWR sky130_fd_sc_hd__fill_1
XFILLER_53_12 VGND VGND VPWR VPWR sky130_fd_sc_hd__decap_3
XFILLER_53_45 VGND VGND VPWR VPWR sky130_fd_sc_hd__decap_3
XFILLER_54_595 VGND VGND VPWR VPWR sky130_fd_sc_hd__decap_3
XFILLER_53_89 VGND VGND VPWR VPWR sky130_fd_sc_hd__decap_3
XFILLER_10_665 VGND VGND VPWR VPWR sky130_fd_sc_hd__decap_3
XFILLER_5_102 VGND VGND VPWR VPWR sky130_fd_sc_hd__decap_3
XFILLER_5_113 VGND VGND VPWR VPWR sky130_fd_sc_hd__decap_3
XFILLER_6_625 VGND VGND VPWR VPWR sky130_fd_sc_hd__decap_3
XFILLER_5_146 VGND VGND VPWR VPWR sky130_fd_sc_hd__decap_3
XFILLER_108_586 VGND VGND VPWR VPWR sky130_fd_sc_hd__fill_2
XTAP_TAPCELL_ROW_114_1615 VGND VPWR sky130_fd_sc_hd__tapvpwrvgnd_1
XFILLER_78_42 VGND VGND VPWR VPWR sky130_fd_sc_hd__decap_3
XFILLER_110_206 VGND VGND VPWR VPWR sky130_fd_sc_hd__decap_3
XFILLER_68_109 VGND VGND VPWR VPWR sky130_fd_sc_hd__decap_3
XFILLER_110_239 VGND VGND VPWR VPWR sky130_fd_sc_hd__fill_2
XFILLER_1_385 VGND VGND VPWR VPWR sky130_fd_sc_hd__decap_3
XFILLER_49_301 VGND VGND VPWR VPWR sky130_fd_sc_hd__decap_3
XFILLER_77_621 VGND VGND VPWR VPWR sky130_fd_sc_hd__decap_3
XFILLER_1_396 VGND VGND VPWR VPWR sky130_fd_sc_hd__decap_3
XFILLER_77_654 VGND VGND VPWR VPWR sky130_fd_sc_hd__decap_3
XFILLER_76_153 VGND VGND VPWR VPWR sky130_fd_sc_hd__decap_3
XFILLER_77_676 VGND VGND VPWR VPWR sky130_fd_sc_hd__decap_3
XFILLER_92_635 VGND VGND VPWR VPWR sky130_fd_sc_hd__decap_3
XFILLER_64_337 VGND VGND VPWR VPWR sky130_fd_sc_hd__decap_3
XFILLER_76_197 VGND VGND VPWR VPWR sky130_fd_sc_hd__decap_3
XFILLER_91_134 VGND VGND VPWR VPWR sky130_fd_sc_hd__decap_3
XFILLER_92_657 VGND VGND VPWR VPWR sky130_fd_sc_hd__decap_3
XFILLER_94_74 VGND VGND VPWR VPWR sky130_fd_sc_hd__decap_3
XFILLER_94_85 VGND VGND VPWR VPWR sky130_fd_sc_hd__decap_3
XFILLER_17_231 VGND VGND VPWR VPWR sky130_fd_sc_hd__decap_3
XFILLER_27_90 VGND VGND VPWR VPWR sky130_fd_sc_hd__decap_3
XFILLER_17_275 VGND VGND VPWR VPWR sky130_fd_sc_hd__decap_3
XFILLER_32_212 VGND VGND VPWR VPWR sky130_fd_sc_hd__decap_3
XFILLER_45_584 VGND VGND VPWR VPWR sky130_fd_sc_hd__fill_1
XFILLER_60_521 VGND VGND VPWR VPWR sky130_fd_sc_hd__decap_3
XFILLER_32_234 VGND VGND VPWR VPWR sky130_fd_sc_hd__fill_2
XTAP_TAPCELL_ROW_15_432 VGND VPWR sky130_fd_sc_hd__tapvpwrvgnd_1
XFILLER_60_576 VGND VGND VPWR VPWR sky130_fd_sc_hd__decap_3
XFILLER_60_598 VGND VGND VPWR VPWR sky130_fd_sc_hd__decap_3
X_3750_ hold963/X _4791_/A1 wire554/X VGND VGND VPWR VPWR _7398_/D sky130_fd_sc_hd__a21bo_2
XTAP_TAPCELL_ROW_43_763 VGND VPWR sky130_fd_sc_hd__tapvpwrvgnd_1
X_3681_ _3674_/Y _3862_/B1 _3887_/A2 _3676_/Y _3680_/X VGND VGND VPWR VPWR _3682_/B
+ sky130_fd_sc_hd__a221o_2
XFILLER_64_3 VGND VGND VPWR VPWR sky130_fd_sc_hd__decap_3
XFILLER_114_545 VGND VGND VPWR VPWR sky130_fd_sc_hd__decap_3
XFILLER_5_691 VGND VGND VPWR VPWR sky130_fd_sc_hd__fill_1
X_5282_ _5282_/A1 _5238_/X _3610_/Y VGND VGND VPWR VPWR _7189_/D sky130_fd_sc_hd__a21o_2
X_4302_ _7224_/Q _3377_/X _3556_/A _4301_/X VGND VGND VPWR VPWR _4302_/X sky130_fd_sc_hd__a211o_2
XFILLER_99_245 VGND VGND VPWR VPWR sky130_fd_sc_hd__decap_3
XFILLER_99_212 VGND VGND VPWR VPWR sky130_fd_sc_hd__decap_3
XFILLER_114_578 VGND VGND VPWR VPWR sky130_fd_sc_hd__decap_3
XFILLER_4_50 VGND VGND VPWR VPWR sky130_fd_sc_hd__decap_3
X_7021_ _7364_/CLK _7021_/D _6301_/Y VGND VGND VPWR VPWR _7021_/Q sky130_fd_sc_hd__dfrtp_2
X_4233_ _7323_/Q _3987_/S _4528_/B _7291_/Q VGND VGND VPWR VPWR _4233_/X sky130_fd_sc_hd__a22o_2
XFILLER_99_278 VGND VGND VPWR VPWR sky130_fd_sc_hd__fill_2
XFILLER_101_228 VGND VGND VPWR VPWR sky130_fd_sc_hd__fill_2
XFILLER_101_239 VGND VGND VPWR VPWR sky130_fd_sc_hd__decap_3
XFILLER_114_589 VGND VGND VPWR VPWR sky130_fd_sc_hd__decap_3
XFILLER_4_83 VGND VGND VPWR VPWR sky130_fd_sc_hd__fill_1
XFILLER_4_94 VGND VGND VPWR VPWR sky130_fd_sc_hd__decap_3
XFILLER_68_632 VGND VGND VPWR VPWR sky130_fd_sc_hd__decap_3
XFILLER_87_429 VGND VGND VPWR VPWR sky130_fd_sc_hd__decap_3
XFILLER_114_18 VGND VGND VPWR VPWR sky130_fd_sc_hd__decap_3
XFILLER_114_29 VGND VGND VPWR VPWR sky130_fd_sc_hd__decap_3
XFILLER_67_131 VGND VGND VPWR VPWR sky130_fd_sc_hd__decap_3
XFILLER_68_654 VGND VGND VPWR VPWR sky130_fd_sc_hd__decap_3
X_4164_ _7105_/Q _4434_/A2 _4352_/B1 _7169_/Q VGND VGND VPWR VPWR _4164_/X sky130_fd_sc_hd__a22o_2
XFILLER_28_518 VGND VGND VPWR VPWR sky130_fd_sc_hd__fill_1
XFILLER_55_315 VGND VGND VPWR VPWR sky130_fd_sc_hd__decap_3
XFILLER_83_613 VGND VGND VPWR VPWR sky130_fd_sc_hd__decap_3
X_4095_ _4095_/A _4210_/B VGND VGND VPWR VPWR _4096_/B sky130_fd_sc_hd__nand2_2
XFILLER_55_337 VGND VGND VPWR VPWR sky130_fd_sc_hd__decap_3
XFILLER_83_635 VGND VGND VPWR VPWR sky130_fd_sc_hd__decap_3
XFILLER_83_668 VGND VGND VPWR VPWR sky130_fd_sc_hd__decap_3
XFILLER_83_679 VGND VGND VPWR VPWR sky130_fd_sc_hd__decap_3
XFILLER_23_223 VGND VGND VPWR VPWR sky130_fd_sc_hd__fill_1
XFILLER_63_370 VGND VGND VPWR VPWR sky130_fd_sc_hd__decap_3
Xplace381 _3378_/Y VGND VGND VPWR VPWR _5229_/C sky130_fd_sc_hd__buf_2
Xplace370 _4799_/A VGND VGND VPWR VPWR _3757_/S sky130_fd_sc_hd__buf_2
X_6805_ _7405_/CLK _6805_/D VGND VGND VPWR VPWR _6805_/Q sky130_fd_sc_hd__dfxtp_2
XFILLER_11_418 VGND VGND VPWR VPWR sky130_fd_sc_hd__decap_3
XFILLER_23_15 VGND VGND VPWR VPWR sky130_fd_sc_hd__decap_3
XFILLER_23_267 VGND VGND VPWR VPWR sky130_fd_sc_hd__decap_3
XFILLER_51_587 VGND VGND VPWR VPWR sky130_fd_sc_hd__decap_3
Xplace392 _3326_/A VGND VGND VPWR VPWR _5648_/A sky130_fd_sc_hd__buf_2
X_6736_ _6970_/CLK _6736_/D VGND VGND VPWR VPWR _6736_/Q sky130_fd_sc_hd__dfxtp_2
X_4997_ _4997_/A1 _6992_/D _4983_/X _4996_/X VGND VGND VPWR VPWR _4997_/X sky130_fd_sc_hd__a211o_2
XFILLER_23_48 VGND VGND VPWR VPWR sky130_fd_sc_hd__decap_3
X_6667_ _6672_/A VGND VGND VPWR VPWR _6667_/Y sky130_fd_sc_hd__inv_2
X_3879_ _6747_/Q _3879_/A2 _3889_/A2 _6735_/Q _3878_/X VGND VGND VPWR VPWR _3879_/X
+ sky130_fd_sc_hd__a221o_2
X_6598_ _6599_/A VGND VGND VPWR VPWR _6598_/Y sky130_fd_sc_hd__inv_2
XFILLER_3_628 VGND VGND VPWR VPWR sky130_fd_sc_hd__decap_3
XFILLER_2_127 VGND VGND VPWR VPWR sky130_fd_sc_hd__decap_3
XFILLER_105_567 VGND VGND VPWR VPWR sky130_fd_sc_hd__decap_3
XFILLER_78_407 VGND VGND VPWR VPWR sky130_fd_sc_hd__decap_3
XFILLER_105_589 VGND VGND VPWR VPWR sky130_fd_sc_hd__decap_3
XFILLER_48_12 VGND VGND VPWR VPWR sky130_fd_sc_hd__decap_3
XFILLER_59_632 VGND VGND VPWR VPWR sky130_fd_sc_hd__decap_3
X_7219_ clkload3/A _7219_/D _6499_/Y VGND VGND VPWR VPWR _7219_/Q sky130_fd_sc_hd__dfrtp_2
XFILLER_59_665 VGND VGND VPWR VPWR sky130_fd_sc_hd__decap_3
XFILLER_86_440 VGND VGND VPWR VPWR sky130_fd_sc_hd__decap_3
XFILLER_100_250 VGND VGND VPWR VPWR sky130_fd_sc_hd__fill_2
XFILLER_46_315 VGND VGND VPWR VPWR sky130_fd_sc_hd__decap_3
XFILLER_48_78 VGND VGND VPWR VPWR sky130_fd_sc_hd__decap_3
XFILLER_58_153 VGND VGND VPWR VPWR sky130_fd_sc_hd__decap_3
XFILLER_59_676 VGND VGND VPWR VPWR sky130_fd_sc_hd__decap_3
XFILLER_100_294 VGND VGND VPWR VPWR sky130_fd_sc_hd__decap_3
XFILLER_104_51 VGND VGND VPWR VPWR sky130_fd_sc_hd__fill_2
XFILLER_58_197 VGND VGND VPWR VPWR sky130_fd_sc_hd__decap_3
XFILLER_74_635 VGND VGND VPWR VPWR sky130_fd_sc_hd__decap_3
XFILLER_74_657 VGND VGND VPWR VPWR sky130_fd_sc_hd__decap_3
XFILLER_27_540 VGND VGND VPWR VPWR sky130_fd_sc_hd__decap_3
XFILLER_61_307 VGND VGND VPWR VPWR sky130_fd_sc_hd__decap_3
XFILLER_64_55 VGND VGND VPWR VPWR sky130_fd_sc_hd__decap_3
XFILLER_73_145 VGND VGND VPWR VPWR sky130_fd_sc_hd__decap_3
XFILLER_14_212 VGND VGND VPWR VPWR sky130_fd_sc_hd__decap_3
XFILLER_64_88 VGND VGND VPWR VPWR sky130_fd_sc_hd__decap_3
XFILLER_82_690 VGND VGND VPWR VPWR sky130_fd_sc_hd__fill_2
XTAP_TAPCELL_ROW_64_1024 VGND VPWR sky130_fd_sc_hd__tapvpwrvgnd_1
XFILLER_14_245 VGND VGND VPWR VPWR sky130_fd_sc_hd__decap_3
XFILLER_14_256 VGND VGND VPWR VPWR sky130_fd_sc_hd__decap_3
XFILLER_42_554 VGND VGND VPWR VPWR sky130_fd_sc_hd__decap_3
XFILLER_54_392 VGND VGND VPWR VPWR sky130_fd_sc_hd__decap_3
XFILLER_80_21 VGND VGND VPWR VPWR sky130_fd_sc_hd__decap_3
XFILLER_9_39 VGND VGND VPWR VPWR sky130_fd_sc_hd__decap_3
XFILLER_80_65 VGND VGND VPWR VPWR sky130_fd_sc_hd__fill_2
Xfanout60 _6587_/A VGND VGND VPWR VPWR _6616_/A sky130_fd_sc_hd__buf_2
Xfanout71 fanout72/X VGND VGND VPWR VPWR _6523_/A sky130_fd_sc_hd__buf_1
XTAP_TAPCELL_ROW_40_733 VGND VPWR sky130_fd_sc_hd__tapvpwrvgnd_1
XFILLER_6_411 VGND VGND VPWR VPWR sky130_fd_sc_hd__decap_3
XFILLER_6_433 VGND VGND VPWR VPWR sky130_fd_sc_hd__decap_3
XFILLER_50_9 VGND VGND VPWR VPWR sky130_fd_sc_hd__decap_3
XFILLER_6_466 VGND VGND VPWR VPWR sky130_fd_sc_hd__fill_2
XFILLER_89_41 VGND VGND VPWR VPWR sky130_fd_sc_hd__decap_3
XTAP_TAPCELL_ROW_20_490 VGND VPWR sky130_fd_sc_hd__tapvpwrvgnd_1
XTAP_TAPCELL_ROW_75_1153 VGND VPWR sky130_fd_sc_hd__tapvpwrvgnd_1
XFILLER_2_672 VGND VGND VPWR VPWR sky130_fd_sc_hd__decap_3
XFILLER_111_548 VGND VGND VPWR VPWR sky130_fd_sc_hd__decap_3
XFILLER_29_6 VGND VGND VPWR VPWR sky130_fd_sc_hd__decap_3
XFILLER_49_175 VGND VGND VPWR VPWR sky130_fd_sc_hd__decap_3
XFILLER_92_410 VGND VGND VPWR VPWR sky130_fd_sc_hd__fill_1
XFILLER_37_348 VGND VGND VPWR VPWR sky130_fd_sc_hd__decap_3
XFILLER_65_635 VGND VGND VPWR VPWR sky130_fd_sc_hd__decap_3
XFILLER_77_495 VGND VGND VPWR VPWR sky130_fd_sc_hd__decap_3
XFILLER_92_421 VGND VGND VPWR VPWR sky130_fd_sc_hd__fill_1
XTAP_TAPCELL_ROW_48_833 VGND VPWR sky130_fd_sc_hd__tapvpwrvgnd_1
XTAP_TAPCELL_ROW_48_822 VGND VPWR sky130_fd_sc_hd__tapvpwrvgnd_1
XFILLER_37_359 VGND VGND VPWR VPWR sky130_fd_sc_hd__fill_2
XFILLER_52_307 VGND VGND VPWR VPWR sky130_fd_sc_hd__fill_1
XFILLER_65_668 VGND VGND VPWR VPWR sky130_fd_sc_hd__decap_3
XFILLER_65_679 VGND VGND VPWR VPWR sky130_fd_sc_hd__decap_3
XFILLER_52_318 VGND VGND VPWR VPWR sky130_fd_sc_hd__decap_3
XFILLER_80_627 VGND VGND VPWR VPWR sky130_fd_sc_hd__decap_3
X_4920_ _4920_/A _4920_/B VGND VGND VPWR VPWR _4920_/Y sky130_fd_sc_hd__xnor2_2
XTAP_TAPCELL_ROW_86_1282 VGND VPWR sky130_fd_sc_hd__tapvpwrvgnd_1
XFILLER_33_532 VGND VGND VPWR VPWR sky130_fd_sc_hd__fill_2
X_4851_ _4633_/A _4142_/X _4849_/Y _4850_/Y _4969_/B VGND VGND VPWR VPWR _4855_/B
+ sky130_fd_sc_hd__o311a_2
XTAP_TAPCELL_ROW_28_590 VGND VPWR sky130_fd_sc_hd__tapvpwrvgnd_1
XFILLER_60_373 VGND VGND VPWR VPWR sky130_fd_sc_hd__decap_3
X_3802_ _3733_/X _3794_/X _3796_/X _3746_/X _3801_/X VGND VGND VPWR VPWR _3802_/X
+ sky130_fd_sc_hd__a221o_2
XFILLER_20_226 VGND VGND VPWR VPWR sky130_fd_sc_hd__decap_3
XFILLER_20_248 VGND VGND VPWR VPWR sky130_fd_sc_hd__decap_3
X_4782_ _4413_/A _4444_/X _4780_/Y _4969_/B VGND VGND VPWR VPWR _4782_/Y sky130_fd_sc_hd__o31ai_2
XPHY_EDGE_ROW_72_Left_189 VGND VGND VPWR VPWR sky130_fd_sc_hd__decap_3
XFILLER_20_259 VGND VGND VPWR VPWR sky130_fd_sc_hd__fill_1
X_6521_ _6587_/A VGND VGND VPWR VPWR _6521_/Y sky130_fd_sc_hd__inv_2
X_3733_ _3746_/A _3741_/B _3733_/C VGND VGND VPWR VPWR _3733_/X sky130_fd_sc_hd__and3_2
XFILLER_109_18 VGND VGND VPWR VPWR sky130_fd_sc_hd__decap_3
X_6452_ _6610_/A VGND VGND VPWR VPWR _6452_/Y sky130_fd_sc_hd__inv_2
Xclkload30 _7406_/CLK VGND VGND VPWR VPWR clkload30/X sky130_fd_sc_hd__clkbuf_1
X_6383_ _6548_/A VGND VGND VPWR VPWR _6383_/Y sky130_fd_sc_hd__inv_2
X_3595_ _4292_/A _3594_/B _3594_/Y _5020_/A VGND VGND VPWR VPWR _3614_/A sky130_fd_sc_hd__a211o_2
XFILLER_0_609 VGND VGND VPWR VPWR sky130_fd_sc_hd__decap_3
XFILLER_114_342 VGND VGND VPWR VPWR sky130_fd_sc_hd__decap_3
XPHY_EDGE_ROW_81_Left_198 VGND VGND VPWR VPWR sky130_fd_sc_hd__decap_3
XFILLER_87_248 VGND VGND VPWR VPWR sky130_fd_sc_hd__decap_3
X_7004_ _7005_/CLK _7004_/D _6284_/Y VGND VGND VPWR VPWR _7004_/Q sky130_fd_sc_hd__dfrtp_2
X_5196_ _5196_/A _5225_/B VGND VGND VPWR VPWR _7230_/D sky130_fd_sc_hd__and2_2
X_4216_ _7068_/Q _4265_/B _4460_/A VGND VGND VPWR VPWR _4371_/B sky130_fd_sc_hd__o21a_2
XFILLER_18_15 VGND VGND VPWR VPWR sky130_fd_sc_hd__decap_3
XFILLER_28_315 VGND VGND VPWR VPWR sky130_fd_sc_hd__fill_2
XFILLER_56_613 VGND VGND VPWR VPWR sky130_fd_sc_hd__decap_3
X_4147_ _7266_/Q _4418_/A2 _3954_/S _7330_/Q _4146_/X VGND VGND VPWR VPWR _4147_/X
+ sky130_fd_sc_hd__a221o_2
XFILLER_110_581 VGND VGND VPWR VPWR sky130_fd_sc_hd__decap_3
XFILLER_110_592 VGND VGND VPWR VPWR sky130_fd_sc_hd__decap_3
XFILLER_56_657 VGND VGND VPWR VPWR sky130_fd_sc_hd__decap_3
XFILLER_83_421 VGND VGND VPWR VPWR sky130_fd_sc_hd__decap_3
XFILLER_95_270 VGND VGND VPWR VPWR sky130_fd_sc_hd__decap_3
XFILLER_55_145 VGND VGND VPWR VPWR sky130_fd_sc_hd__decap_3
X_4078_ _7025_/Q _4437_/A2 _4435_/B1 _7371_/Q VGND VGND VPWR VPWR _4078_/X sky130_fd_sc_hd__a22o_2
XFILLER_43_329 VGND VGND VPWR VPWR sky130_fd_sc_hd__decap_3
XFILLER_55_189 VGND VGND VPWR VPWR sky130_fd_sc_hd__decap_3
XFILLER_64_690 VGND VGND VPWR VPWR sky130_fd_sc_hd__fill_2
XFILLER_70_115 VGND VGND VPWR VPWR sky130_fd_sc_hd__decap_3
XFILLER_71_638 VGND VGND VPWR VPWR sky130_fd_sc_hd__decap_3
XFILLER_51_340 VGND VGND VPWR VPWR sky130_fd_sc_hd__decap_3
XFILLER_70_159 VGND VGND VPWR VPWR sky130_fd_sc_hd__decap_3
XFILLER_24_565 VGND VGND VPWR VPWR sky130_fd_sc_hd__decap_3
XFILLER_34_47 VGND VGND VPWR VPWR sky130_fd_sc_hd__decap_3
XFILLER_34_58 VGND VGND VPWR VPWR sky130_fd_sc_hd__decap_3
XFILLER_51_373 VGND VGND VPWR VPWR sky130_fd_sc_hd__decap_3
XFILLER_11_237 VGND VGND VPWR VPWR sky130_fd_sc_hd__decap_3
XFILLER_7_208 VGND VGND VPWR VPWR sky130_fd_sc_hd__decap_3
Xclkload2 clkload2/A VGND VGND VPWR VPWR clkload2/X sky130_fd_sc_hd__clkbuf_1
X_6719_ _6976_/CLK _6719_/D VGND VGND VPWR VPWR _6719_/Q sky130_fd_sc_hd__dfxtp_2
XFILLER_109_125 VGND VGND VPWR VPWR sky130_fd_sc_hd__decap_3
XFILLER_50_46 VGND VGND VPWR VPWR sky130_fd_sc_hd__decap_3
XFILLER_109_158 VGND VGND VPWR VPWR sky130_fd_sc_hd__decap_3
XFILLER_109_169 VGND VGND VPWR VPWR sky130_fd_sc_hd__fill_1
XFILLER_3_414 VGND VGND VPWR VPWR sky130_fd_sc_hd__decap_3
XFILLER_3_447 VGND VGND VPWR VPWR sky130_fd_sc_hd__fill_1
XFILLER_3_458 VGND VGND VPWR VPWR sky130_fd_sc_hd__decap_3
XFILLER_105_386 VGND VGND VPWR VPWR sky130_fd_sc_hd__decap_3
XFILLER_59_66 VGND VGND VPWR VPWR sky130_fd_sc_hd__decap_3
XFILLER_59_440 VGND VGND VPWR VPWR sky130_fd_sc_hd__fill_1
XFILLER_115_50 VGND VGND VPWR VPWR sky130_fd_sc_hd__decap_3
XFILLER_115_72 VGND VGND VPWR VPWR sky130_fd_sc_hd__decap_3
XFILLER_47_613 VGND VGND VPWR VPWR sky130_fd_sc_hd__decap_3
XFILLER_19_337 VGND VGND VPWR VPWR sky130_fd_sc_hd__fill_1
XFILLER_46_123 VGND VGND VPWR VPWR sky130_fd_sc_hd__decap_3
XFILLER_47_635 VGND VGND VPWR VPWR sky130_fd_sc_hd__decap_3
XFILLER_74_421 VGND VGND VPWR VPWR sky130_fd_sc_hd__decap_3
XFILLER_75_32 VGND VGND VPWR VPWR sky130_fd_sc_hd__decap_3
XFILLER_86_292 VGND VGND VPWR VPWR sky130_fd_sc_hd__decap_3
XTAP_TAPCELL_ROW_70_1094 VGND VPWR sky130_fd_sc_hd__tapvpwrvgnd_1
XFILLER_46_156 VGND VGND VPWR VPWR sky130_fd_sc_hd__decap_3
XFILLER_47_668 VGND VGND VPWR VPWR sky130_fd_sc_hd__decap_3
XFILLER_47_679 VGND VGND VPWR VPWR sky130_fd_sc_hd__decap_3
XFILLER_62_616 VGND VGND VPWR VPWR sky130_fd_sc_hd__decap_3
XFILLER_74_465 VGND VGND VPWR VPWR sky130_fd_sc_hd__decap_3
XFILLER_75_98 VGND VGND VPWR VPWR sky130_fd_sc_hd__decap_3
XTAP_TAPCELL_ROW_109_1558 VGND VPWR sky130_fd_sc_hd__tapvpwrvgnd_1
XFILLER_15_521 VGND VGND VPWR VPWR sky130_fd_sc_hd__fill_2
XFILLER_34_318 VGND VGND VPWR VPWR sky130_fd_sc_hd__decap_3
XFILLER_15_543 VGND VGND VPWR VPWR sky130_fd_sc_hd__decap_3
XFILLER_61_148 VGND VGND VPWR VPWR sky130_fd_sc_hd__decap_3
XFILLER_91_42 VGND VGND VPWR VPWR sky130_fd_sc_hd__fill_2
XFILLER_42_362 VGND VGND VPWR VPWR sky130_fd_sc_hd__fill_2
XFILLER_42_373 VGND VGND VPWR VPWR sky130_fd_sc_hd__decap_3
XFILLER_70_660 VGND VGND VPWR VPWR sky130_fd_sc_hd__decap_3
XFILLER_98_9 VGND VGND VPWR VPWR sky130_fd_sc_hd__decap_3
XTAP_TAPCELL_ROW_53_891 VGND VPWR sky130_fd_sc_hd__tapvpwrvgnd_1
XFILLER_24_91 VGND VGND VPWR VPWR sky130_fd_sc_hd__decap_3
XFILLER_30_579 VGND VGND VPWR VPWR sky130_fd_sc_hd__decap_3
XFILLER_116_629 VGND VGND VPWR VPWR sky130_fd_sc_hd__fill_1
Xhold709 _6963_/Q VGND VGND VPWR VPWR _6963_/D sky130_fd_sc_hd__dlygate4sd3_1
XFILLER_115_128 VGND VGND VPWR VPWR sky130_fd_sc_hd__decap_3
XFILLER_6_296 VGND VGND VPWR VPWR sky130_fd_sc_hd__decap_3
XFILLER_108_180 VGND VGND VPWR VPWR sky130_fd_sc_hd__decap_3
XFILLER_97_502 VGND VGND VPWR VPWR sky130_fd_sc_hd__fill_2
X_3380_ _3528_/A _5118_/D VGND VGND VPWR VPWR _3380_/Y sky130_fd_sc_hd__nor2_2
XFILLER_69_237 VGND VGND VPWR VPWR sky130_fd_sc_hd__decap_3
X_5050_ _5086_/A _5101_/B _5100_/B _4366_/X VGND VGND VPWR VPWR _5050_/X sky130_fd_sc_hd__a31o_2
XFILLER_27_3 VGND VGND VPWR VPWR sky130_fd_sc_hd__decap_3
XFILLER_77_281 VGND VGND VPWR VPWR sky130_fd_sc_hd__fill_2
XFILLER_77_292 VGND VGND VPWR VPWR sky130_fd_sc_hd__decap_3
XFILLER_84_229 VGND VGND VPWR VPWR sky130_fd_sc_hd__decap_3
XTAP_TAPCELL_ROW_88_1311 VGND VPWR sky130_fd_sc_hd__tapvpwrvgnd_1
XFILLER_1_84 VGND VGND VPWR VPWR sky130_fd_sc_hd__decap_3
XFILLER_37_189 VGND VGND VPWR VPWR sky130_fd_sc_hd__decap_3
XFILLER_53_638 VGND VGND VPWR VPWR sky130_fd_sc_hd__decap_3
XFILLER_80_424 VGND VGND VPWR VPWR sky130_fd_sc_hd__decap_3
XFILLER_46_690 VGND VGND VPWR VPWR sky130_fd_sc_hd__fill_2
XFILLER_52_137 VGND VGND VPWR VPWR sky130_fd_sc_hd__decap_3
X_4903_ _4903_/A _4903_/B _4903_/C VGND VGND VPWR VPWR _4903_/X sky130_fd_sc_hd__and3_2
XFILLER_21_502 VGND VGND VPWR VPWR sky130_fd_sc_hd__fill_2
XFILLER_33_340 VGND VGND VPWR VPWR sky130_fd_sc_hd__decap_3
XFILLER_61_671 VGND VGND VPWR VPWR sky130_fd_sc_hd__fill_1
XFILLER_61_682 VGND VGND VPWR VPWR sky130_fd_sc_hd__decap_3
XFILLER_21_524 VGND VGND VPWR VPWR sky130_fd_sc_hd__fill_2
X_4834_ _4834_/A _4834_/B VGND VGND VPWR VPWR _4834_/Y sky130_fd_sc_hd__nor2_2
X_4765_ _4765_/A _4765_/B VGND VGND VPWR VPWR _4766_/A sky130_fd_sc_hd__and2_2
X_6504_ _6570_/A VGND VGND VPWR VPWR _6504_/Y sky130_fd_sc_hd__inv_2
XTAP_TAPCELL_ROW_99_1440 VGND VPWR sky130_fd_sc_hd__tapvpwrvgnd_1
XFILLER_107_607 VGND VGND VPWR VPWR sky130_fd_sc_hd__decap_3
XFILLER_107_629 VGND VGND VPWR VPWR sky130_fd_sc_hd__decap_3
X_4696_ _5118_/C _4696_/B VGND VGND VPWR VPWR _5670_/B sky130_fd_sc_hd__nor2_2
XFILLER_106_106 VGND VGND VPWR VPWR sky130_fd_sc_hd__fill_1
XFILLER_106_117 VGND VGND VPWR VPWR sky130_fd_sc_hd__decap_3
XFILLER_20_27 VGND VGND VPWR VPWR sky130_fd_sc_hd__fill_1
XFILLER_20_49 VGND VGND VPWR VPWR sky130_fd_sc_hd__decap_3
X_6435_ _6599_/A VGND VGND VPWR VPWR _6435_/Y sky130_fd_sc_hd__inv_2
XFILLER_115_662 VGND VGND VPWR VPWR sky130_fd_sc_hd__decap_3
X_6366_ _6366_/A VGND VGND VPWR VPWR _6366_/Y sky130_fd_sc_hd__inv_2
X_3578_ _7284_/Q _3415_/X _3417_/X _7092_/Q VGND VGND VPWR VPWR _3583_/A sky130_fd_sc_hd__a22o_2
XFILLER_102_301 VGND VGND VPWR VPWR sky130_fd_sc_hd__decap_3
XFILLER_102_312 VGND VGND VPWR VPWR sky130_fd_sc_hd__decap_3
XFILLER_114_150 VGND VGND VPWR VPWR sky130_fd_sc_hd__decap_3
XFILLER_115_673 VGND VGND VPWR VPWR sky130_fd_sc_hd__decap_3
XFILLER_88_524 VGND VGND VPWR VPWR sky130_fd_sc_hd__decap_3
X_5317_ _5317_/A0 _4899_/X _7412_/A VGND VGND VPWR VPWR _7172_/D sky130_fd_sc_hd__mux2_2
XFILLER_114_183 VGND VGND VPWR VPWR sky130_fd_sc_hd__decap_3
XFILLER_88_546 VGND VGND VPWR VPWR sky130_fd_sc_hd__fill_1
X_6297_ _6548_/A VGND VGND VPWR VPWR _6297_/Y sky130_fd_sc_hd__inv_2
XFILLER_102_356 VGND VGND VPWR VPWR sky130_fd_sc_hd__decap_3
XFILLER_29_613 VGND VGND VPWR VPWR sky130_fd_sc_hd__decap_3
XFILLER_28_101 VGND VGND VPWR VPWR sky130_fd_sc_hd__decap_3
XFILLER_68_292 VGND VGND VPWR VPWR sky130_fd_sc_hd__decap_3
X_5179_ _5179_/A _5182_/B VGND VGND VPWR VPWR _7238_/D sky130_fd_sc_hd__and2_2
XFILLER_28_134 VGND VGND VPWR VPWR sky130_fd_sc_hd__decap_3
XFILLER_16_307 VGND VGND VPWR VPWR sky130_fd_sc_hd__fill_1
XFILLER_16_318 VGND VGND VPWR VPWR sky130_fd_sc_hd__decap_3
XFILLER_71_402 VGND VGND VPWR VPWR sky130_fd_sc_hd__fill_1
XTAP_TAPCELL_ROW_3_288 VGND VPWR sky130_fd_sc_hd__tapvpwrvgnd_1
XFILLER_52_660 VGND VGND VPWR VPWR sky130_fd_sc_hd__decap_3
XFILLER_101_74 VGND VGND VPWR VPWR sky130_fd_sc_hd__decap_3
XFILLER_24_373 VGND VGND VPWR VPWR sky130_fd_sc_hd__decap_3
XFILLER_61_12 VGND VGND VPWR VPWR sky130_fd_sc_hd__decap_3
XTAP_TAPCELL_ROW_104_1499 VGND VPWR sky130_fd_sc_hd__tapvpwrvgnd_1
XTAP_TAPCELL_ROW_50_850 VGND VPWR sky130_fd_sc_hd__tapvpwrvgnd_1
XFILLER_6_18 VGND VGND VPWR VPWR sky130_fd_sc_hd__decap_3
XFILLER_6_29 VGND VGND VPWR VPWR sky130_fd_sc_hd__decap_3
XFILLER_106_651 VGND VGND VPWR VPWR sky130_fd_sc_hd__decap_3
XFILLER_3_222 VGND VGND VPWR VPWR sky130_fd_sc_hd__fill_2
XFILLER_106_684 VGND VGND VPWR VPWR sky130_fd_sc_hd__decap_3
XFILLER_10_71 VGND VGND VPWR VPWR sky130_fd_sc_hd__decap_3
XFILLER_112_109 VGND VGND VPWR VPWR sky130_fd_sc_hd__decap_3
XTAP_TAPCELL_ROW_72_1112 VGND VPWR sky130_fd_sc_hd__tapvpwrvgnd_1
XFILLER_79_557 VGND VGND VPWR VPWR sky130_fd_sc_hd__decap_3
XFILLER_86_64 VGND VGND VPWR VPWR sky130_fd_sc_hd__fill_2
XFILLER_19_101 VGND VGND VPWR VPWR sky130_fd_sc_hd__decap_3
XFILLER_59_281 VGND VGND VPWR VPWR sky130_fd_sc_hd__fill_2
XFILLER_86_97 VGND VGND VPWR VPWR sky130_fd_sc_hd__decap_3
XFILLER_19_145 VGND VGND VPWR VPWR sky130_fd_sc_hd__fill_2
XFILLER_47_465 VGND VGND VPWR VPWR sky130_fd_sc_hd__decap_3
XTAP_TAPCELL_ROW_58_950 VGND VPWR sky130_fd_sc_hd__tapvpwrvgnd_1
XFILLER_19_178 VGND VGND VPWR VPWR sky130_fd_sc_hd__decap_3
XFILLER_47_498 VGND VGND VPWR VPWR sky130_fd_sc_hd__decap_3
XFILLER_62_402 VGND VGND VPWR VPWR sky130_fd_sc_hd__decap_3
XFILLER_62_424 VGND VGND VPWR VPWR sky130_fd_sc_hd__fill_2
XFILLER_74_251 VGND VGND VPWR VPWR sky130_fd_sc_hd__fill_1
XFILLER_74_262 VGND VGND VPWR VPWR sky130_fd_sc_hd__decap_3
XFILLER_62_435 VGND VGND VPWR VPWR sky130_fd_sc_hd__decap_3
XTAP_TAPCELL_ROW_83_1252 VGND VPWR sky130_fd_sc_hd__tapvpwrvgnd_1
XFILLER_43_682 VGND VGND VPWR VPWR sky130_fd_sc_hd__decap_3
XFILLER_30_365 VGND VGND VPWR VPWR sky130_fd_sc_hd__decap_3
X_4550_ _4550_/A _4563_/B VGND VGND VPWR VPWR _7305_/D sky130_fd_sc_hd__and2_2
XFILLER_7_561 VGND VGND VPWR VPWR sky130_fd_sc_hd__decap_3
X_3501_ _5144_/A _5144_/B _3500_/Y VGND VGND VPWR VPWR _3501_/X sky130_fd_sc_hd__a21o_2
XFILLER_116_459 VGND VGND VPWR VPWR sky130_fd_sc_hd__decap_3
XFILLER_112_610 VGND VGND VPWR VPWR sky130_fd_sc_hd__decap_3
X_3363_ _3561_/A _4697_/A _3362_/A VGND VGND VPWR VPWR _5294_/B sky130_fd_sc_hd__or3b_4
XTAP_TAPCELL_ROW_94_1381 VGND VPWR sky130_fd_sc_hd__tapvpwrvgnd_1
XFILLER_112_643 VGND VGND VPWR VPWR sky130_fd_sc_hd__fill_1
XFILLER_112_654 VGND VGND VPWR VPWR sky130_fd_sc_hd__decap_3
XFILLER_97_332 VGND VGND VPWR VPWR sky130_fd_sc_hd__decap_3
X_5102_ _5114_/A _4343_/X _5100_/Y _3618_/X _5101_/Y VGND VGND VPWR VPWR _5102_/X
+ sky130_fd_sc_hd__a221o_2
XFILLER_111_131 VGND VGND VPWR VPWR sky130_fd_sc_hd__decap_3
XFILLER_112_687 VGND VGND VPWR VPWR sky130_fd_sc_hd__decap_3
XFILLER_57_207 VGND VGND VPWR VPWR sky130_fd_sc_hd__decap_3
Xhold1206 _7179_/Q VGND VGND VPWR VPWR _5302_/A0 sky130_fd_sc_hd__dlygate4sd3_1
XFILLER_111_164 VGND VGND VPWR VPWR sky130_fd_sc_hd__decap_3
XFILLER_111_175 VGND VGND VPWR VPWR sky130_fd_sc_hd__decap_3
XFILLER_57_218 VGND VGND VPWR VPWR sky130_fd_sc_hd__decap_3
XFILLER_85_538 VGND VGND VPWR VPWR sky130_fd_sc_hd__decap_3
XFILLER_97_387 VGND VGND VPWR VPWR sky130_fd_sc_hd__decap_3
Xhold1217 _3983_/X VGND VGND VPWR VPWR _7349_/D sky130_fd_sc_hd__dlygate4sd3_1
Xhold1228 _7292_/Q VGND VGND VPWR VPWR _4577_/A sky130_fd_sc_hd__dlygate4sd3_1
X_5033_ _5072_/A _4629_/Y _5032_/A _5033_/B2 VGND VGND VPWR VPWR _5033_/X sky130_fd_sc_hd__a22o_2
XFILLER_53_402 VGND VGND VPWR VPWR sky130_fd_sc_hd__decap_3
XTAP_TAPCELL_ROW_0_236 VGND VPWR sky130_fd_sc_hd__tapvpwrvgnd_1
XFILLER_19_690 VGND VGND VPWR VPWR sky130_fd_sc_hd__fill_2
XFILLER_25_137 VGND VGND VPWR VPWR sky130_fd_sc_hd__decap_3
X_6984_ _7266_/CLK _6984_/D _6264_/Y VGND VGND VPWR VPWR _6984_/Q sky130_fd_sc_hd__dfrtp_2
XTAP_TAPCELL_ROW_0_247 VGND VPWR sky130_fd_sc_hd__tapvpwrvgnd_1
XFILLER_15_27 VGND VGND VPWR VPWR sky130_fd_sc_hd__decap_3
XFILLER_80_298 VGND VGND VPWR VPWR sky130_fd_sc_hd__decap_3
XTAP_TAPCELL_ROW_36_688 VGND VPWR sky130_fd_sc_hd__tapvpwrvgnd_1
X_4817_ _4810_/X _4811_/X _4815_/X _4816_/X VGND VGND VPWR VPWR _5663_/B sky130_fd_sc_hd__a211o_2
XFILLER_21_387 VGND VGND VPWR VPWR sky130_fd_sc_hd__decap_3
XFILLER_31_15 VGND VGND VPWR VPWR sky130_fd_sc_hd__decap_3
X_4748_ _3683_/Y _5664_/B _3509_/B VGND VGND VPWR VPWR _4751_/A sky130_fd_sc_hd__a21o_2
X_4679_ _6990_/Q _5014_/B VGND VGND VPWR VPWR _5015_/B sky130_fd_sc_hd__nand2_2
X_6418_ _6578_/A VGND VGND VPWR VPWR _6418_/Y sky130_fd_sc_hd__inv_2
XPHY_EDGE_ROW_1_Right_1 VGND VGND VPWR VPWR sky130_fd_sc_hd__decap_3
X_7398_ _7398_/CLK _7398_/D _6678_/Y VGND VGND VPWR VPWR _7398_/Q sky130_fd_sc_hd__dfrtp_2
XFILLER_0_225 VGND VGND VPWR VPWR sky130_fd_sc_hd__decap_3
XFILLER_103_632 VGND VGND VPWR VPWR sky130_fd_sc_hd__decap_3
XFILLER_88_332 VGND VGND VPWR VPWR sky130_fd_sc_hd__decap_3
X_6349_ _6540_/A VGND VGND VPWR VPWR _6349_/Y sky130_fd_sc_hd__inv_2
XTAP_TAPCELL_ROW_8_347 VGND VPWR sky130_fd_sc_hd__tapvpwrvgnd_1
XFILLER_103_665 VGND VGND VPWR VPWR sky130_fd_sc_hd__decap_3
XFILLER_103_676 VGND VGND VPWR VPWR sky130_fd_sc_hd__decap_3
XFILLER_88_354 VGND VGND VPWR VPWR sky130_fd_sc_hd__fill_2
XFILLER_88_365 VGND VGND VPWR VPWR sky130_fd_sc_hd__decap_3
XFILLER_56_12 VGND VGND VPWR VPWR sky130_fd_sc_hd__decap_3
XFILLER_88_398 VGND VGND VPWR VPWR sky130_fd_sc_hd__decap_3
XFILLER_29_443 VGND VGND VPWR VPWR sky130_fd_sc_hd__decap_3
XFILLER_56_45 VGND VGND VPWR VPWR sky130_fd_sc_hd__decap_3
XFILLER_16_104 VGND VGND VPWR VPWR sky130_fd_sc_hd__decap_3
XFILLER_17_627 VGND VGND VPWR VPWR sky130_fd_sc_hd__decap_3
XFILLER_44_402 VGND VGND VPWR VPWR sky130_fd_sc_hd__decap_3
XFILLER_56_251 VGND VGND VPWR VPWR sky130_fd_sc_hd__fill_1
XFILLER_56_262 VGND VGND VPWR VPWR sky130_fd_sc_hd__decap_3
XFILLER_56_78 VGND VGND VPWR VPWR sky130_fd_sc_hd__decap_3
XFILLER_16_137 VGND VGND VPWR VPWR sky130_fd_sc_hd__decap_3
XFILLER_17_649 VGND VGND VPWR VPWR sky130_fd_sc_hd__decap_3
XFILLER_44_457 VGND VGND VPWR VPWR sky130_fd_sc_hd__decap_3
XTAP_TAPCELL_ROW_106_1528 VGND VPWR sky130_fd_sc_hd__tapvpwrvgnd_1
XFILLER_112_62 VGND VGND VPWR VPWR sky130_fd_sc_hd__decap_3
XFILLER_25_660 VGND VGND VPWR VPWR sky130_fd_sc_hd__fill_1
XFILLER_71_265 VGND VGND VPWR VPWR sky130_fd_sc_hd__decap_3
XFILLER_25_682 VGND VGND VPWR VPWR sky130_fd_sc_hd__fill_2
XFILLER_71_298 VGND VGND VPWR VPWR sky130_fd_sc_hd__decap_3
XFILLER_72_55 VGND VGND VPWR VPWR sky130_fd_sc_hd__decap_3
XFILLER_12_343 VGND VGND VPWR VPWR sky130_fd_sc_hd__decap_3
XFILLER_72_88 VGND VGND VPWR VPWR sky130_fd_sc_hd__decap_3
XFILLER_40_685 VGND VGND VPWR VPWR sky130_fd_sc_hd__decap_3
XFILLER_113_418 VGND VGND VPWR VPWR sky130_fd_sc_hd__decap_3
XFILLER_113_429 VGND VGND VPWR VPWR sky130_fd_sc_hd__decap_3
XFILLER_4_564 VGND VGND VPWR VPWR sky130_fd_sc_hd__fill_1
XFILLER_97_30 VGND VGND VPWR VPWR sky130_fd_sc_hd__decap_3
XFILLER_79_321 VGND VGND VPWR VPWR sky130_fd_sc_hd__decap_3
XFILLER_79_343 VGND VGND VPWR VPWR sky130_fd_sc_hd__decap_3
XFILLER_67_505 VGND VGND VPWR VPWR sky130_fd_sc_hd__decap_3
XFILLER_39_218 VGND VGND VPWR VPWR sky130_fd_sc_hd__decap_3
XFILLER_79_387 VGND VGND VPWR VPWR sky130_fd_sc_hd__decap_3
XFILLER_94_335 VGND VGND VPWR VPWR sky130_fd_sc_hd__decap_3
XFILLER_11_6 VGND VGND VPWR VPWR sky130_fd_sc_hd__decap_3
XFILLER_47_240 VGND VGND VPWR VPWR sky130_fd_sc_hd__decap_3
XFILLER_94_368 VGND VGND VPWR VPWR sky130_fd_sc_hd__decap_3
XFILLER_35_402 VGND VGND VPWR VPWR sky130_fd_sc_hd__decap_3
XFILLER_47_273 VGND VGND VPWR VPWR sky130_fd_sc_hd__decap_3
XFILLER_75_593 VGND VGND VPWR VPWR sky130_fd_sc_hd__decap_3
XFILLER_16_660 VGND VGND VPWR VPWR sky130_fd_sc_hd__fill_1
XFILLER_62_265 VGND VGND VPWR VPWR sky130_fd_sc_hd__decap_3
X_3981_ _7350_/Q _7318_/Q _3987_/S VGND VGND VPWR VPWR _7350_/D sky130_fd_sc_hd__mux2_2
XFILLER_22_129 VGND VGND VPWR VPWR sky130_fd_sc_hd__fill_1
XFILLER_15_192 VGND VGND VPWR VPWR sky130_fd_sc_hd__decap_3
XFILLER_94_3 VGND VGND VPWR VPWR sky130_fd_sc_hd__decap_3
Xclkbuf_leaf_42_clk clkbuf_3_0__f_clk/X VGND VGND VPWR VPWR clkload3/A sky130_fd_sc_hd__clkbuf_16
XTAP_TAPCELL_ROW_61_978 VGND VPWR sky130_fd_sc_hd__tapvpwrvgnd_1
XTAP_TAPCELL_ROW_33_647 VGND VPWR sky130_fd_sc_hd__tapvpwrvgnd_1
XFILLER_30_162 VGND VGND VPWR VPWR sky130_fd_sc_hd__decap_3
X_5651_ _5651_/A VGND VGND VPWR VPWR _5651_/Y sky130_fd_sc_hd__inv_2
XTAP_TAPCELL_ROW_61_989 VGND VPWR sky130_fd_sc_hd__tapvpwrvgnd_1
XFILLER_30_195 VGND VGND VPWR VPWR sky130_fd_sc_hd__fill_1
XFILLER_116_212 VGND VGND VPWR VPWR sky130_fd_sc_hd__fill_2
XFILLER_7_72 VGND VGND VPWR VPWR sky130_fd_sc_hd__decap_3
X_7321_ _7360_/CLK _7321_/D _6601_/Y VGND VGND VPWR VPWR _7321_/Q sky130_fd_sc_hd__dfrtp_2
XFILLER_116_234 VGND VGND VPWR VPWR sky130_fd_sc_hd__decap_3
X_7252_ clkload5/A _7252_/D _6532_/Y VGND VGND VPWR VPWR _7252_/Q sky130_fd_sc_hd__dfrtp_2
XFILLER_116_256 VGND VGND VPWR VPWR sky130_fd_sc_hd__decap_3
XFILLER_116_289 VGND VGND VPWR VPWR sky130_fd_sc_hd__decap_3
X_4464_ _3541_/X _3610_/B _4463_/X VGND VGND VPWR VPWR _5655_/C sky130_fd_sc_hd__o21ai_2
XFILLER_89_129 VGND VGND VPWR VPWR sky130_fd_sc_hd__decap_3
X_7183_ _7387_/CLK _7183_/D _6463_/Y VGND VGND VPWR VPWR _7183_/Q sky130_fd_sc_hd__dfrtp_2
X_4395_ _4396_/A _4444_/B VGND VGND VPWR VPWR _4397_/A sky130_fd_sc_hd__and2_2
X_3415_ _3449_/B _3449_/C _3417_/C VGND VGND VPWR VPWR _3415_/X sky130_fd_sc_hd__and3_4
XFILLER_98_630 VGND VGND VPWR VPWR sky130_fd_sc_hd__decap_3
X_3346_ _3346_/A VGND VGND VPWR VPWR _3347_/B sky130_fd_sc_hd__inv_2
XTAP_TAPCELL_ROW_5_317 VGND VPWR sky130_fd_sc_hd__tapvpwrvgnd_1
XTAP_TAPCELL_ROW_5_306 VGND VPWR sky130_fd_sc_hd__tapvpwrvgnd_1
XFILLER_98_663 VGND VGND VPWR VPWR sky130_fd_sc_hd__decap_3
XFILLER_100_635 VGND VGND VPWR VPWR sky130_fd_sc_hd__decap_3
XFILLER_112_495 VGND VGND VPWR VPWR sky130_fd_sc_hd__decap_3
XFILLER_85_335 VGND VGND VPWR VPWR sky130_fd_sc_hd__fill_1
Xhold1003 _7376_/Q VGND VGND VPWR VPWR _3924_/A1 sky130_fd_sc_hd__dlygate4sd3_1
Xhold1014 _7198_/Q VGND VGND VPWR VPWR _5264_/A0 sky130_fd_sc_hd__dlygate4sd3_1
XFILLER_100_657 VGND VGND VPWR VPWR sky130_fd_sc_hd__decap_3
Xhold1025 _7203_/Q VGND VGND VPWR VPWR _5253_/A0 sky130_fd_sc_hd__dlygate4sd3_1
Xhold1036 _7244_/Q VGND VGND VPWR VPWR _5167_/A sky130_fd_sc_hd__dlygate4sd3_1
Xhold1047 _7404_/Q VGND VGND VPWR VPWR _3684_/A1 sky130_fd_sc_hd__dlygate4sd3_1
Xhold1058 _7212_/Q VGND VGND VPWR VPWR _5236_/A0 sky130_fd_sc_hd__dlygate4sd3_1
X_5016_ _5032_/A _5031_/B _4629_/Y VGND VGND VPWR VPWR _5017_/B sky130_fd_sc_hd__a21oi_2
XFILLER_26_15 VGND VGND VPWR VPWR sky130_fd_sc_hd__decap_3
XFILLER_38_262 VGND VGND VPWR VPWR sky130_fd_sc_hd__decap_3
XFILLER_66_582 VGND VGND VPWR VPWR sky130_fd_sc_hd__decap_3
Xhold1069 _7277_/Q VGND VGND VPWR VPWR _4735_/A0 sky130_fd_sc_hd__dlygate4sd3_1
XFILLER_26_435 VGND VGND VPWR VPWR sky130_fd_sc_hd__decap_3
XFILLER_26_48 VGND VGND VPWR VPWR sky130_fd_sc_hd__decap_3
XFILLER_38_284 VGND VGND VPWR VPWR sky130_fd_sc_hd__decap_3
XFILLER_53_210 VGND VGND VPWR VPWR sky130_fd_sc_hd__decap_3
XFILLER_93_390 VGND VGND VPWR VPWR sky130_fd_sc_hd__fill_2
XFILLER_53_243 VGND VGND VPWR VPWR sky130_fd_sc_hd__decap_3
X_6967_ _6970_/CLK _6967_/D VGND VGND VPWR VPWR _6967_/Q sky130_fd_sc_hd__dfxtp_2
XFILLER_13_107 VGND VGND VPWR VPWR sky130_fd_sc_hd__fill_2
XFILLER_41_427 VGND VGND VPWR VPWR sky130_fd_sc_hd__decap_3
XFILLER_41_449 VGND VGND VPWR VPWR sky130_fd_sc_hd__fill_1
XFILLER_53_276 VGND VGND VPWR VPWR sky130_fd_sc_hd__decap_3
XFILLER_53_287 VGND VGND VPWR VPWR sky130_fd_sc_hd__decap_3
XFILLER_22_641 VGND VGND VPWR VPWR sky130_fd_sc_hd__decap_3
Xclkbuf_leaf_33_clk clkbuf_3_0__f_clk/X VGND VGND VPWR VPWR clkload2/A sky130_fd_sc_hd__clkbuf_16
X_6898_ _6909_/CLK _6898_/D VGND VGND VPWR VPWR _6898_/Q sky130_fd_sc_hd__dfxtp_2
XFILLER_21_162 VGND VGND VPWR VPWR sky130_fd_sc_hd__decap_3
XFILLER_22_685 VGND VGND VPWR VPWR sky130_fd_sc_hd__decap_3
XTAP_TAPCELL_ROW_101_1469 VGND VPWR sky130_fd_sc_hd__tapvpwrvgnd_1
XTAP_TAPCELL_ROW_101_1458 VGND VPWR sky130_fd_sc_hd__tapvpwrvgnd_1
XFILLER_21_184 VGND VGND VPWR VPWR sky130_fd_sc_hd__decap_3
XFILLER_107_223 VGND VGND VPWR VPWR sky130_fd_sc_hd__fill_1
XFILLER_1_534 VGND VGND VPWR VPWR sky130_fd_sc_hd__fill_1
XFILLER_89_641 VGND VGND VPWR VPWR sky130_fd_sc_hd__decap_3
Xhold870 _7117_/Q VGND VGND VPWR VPWR _7117_/D sky130_fd_sc_hd__dlygate4sd3_1
Xhold881 _7116_/Q VGND VGND VPWR VPWR _7116_/D sky130_fd_sc_hd__dlygate4sd3_1
XFILLER_107_84 VGND VGND VPWR VPWR sky130_fd_sc_hd__decap_3
XFILLER_1_567 VGND VGND VPWR VPWR sky130_fd_sc_hd__decap_3
Xhold892 _7081_/Q VGND VGND VPWR VPWR _7081_/D sky130_fd_sc_hd__dlygate4sd3_1
XFILLER_103_473 VGND VGND VPWR VPWR sky130_fd_sc_hd__fill_2
XFILLER_103_495 VGND VGND VPWR VPWR sky130_fd_sc_hd__decap_3
XFILLER_67_33 VGND VGND VPWR VPWR sky130_fd_sc_hd__decap_3
XFILLER_76_324 VGND VGND VPWR VPWR sky130_fd_sc_hd__decap_3
XFILLER_88_184 VGND VGND VPWR VPWR sky130_fd_sc_hd__decap_3
XFILLER_89_685 VGND VGND VPWR VPWR sky130_fd_sc_hd__decap_3
XTAP_TAPCELL_ROW_112_1598 VGND VPWR sky130_fd_sc_hd__tapvpwrvgnd_1
XFILLER_67_99 VGND VGND VPWR VPWR sky130_fd_sc_hd__fill_1
XFILLER_29_251 VGND VGND VPWR VPWR sky130_fd_sc_hd__fill_2
XFILLER_29_273 VGND VGND VPWR VPWR sky130_fd_sc_hd__decap_3
XFILLER_57_582 VGND VGND VPWR VPWR sky130_fd_sc_hd__decap_3
XFILLER_91_305 VGND VGND VPWR VPWR sky130_fd_sc_hd__decap_3
XFILLER_17_424 VGND VGND VPWR VPWR sky130_fd_sc_hd__decap_3
XFILLER_29_295 VGND VGND VPWR VPWR sky130_fd_sc_hd__decap_3
XFILLER_44_210 VGND VGND VPWR VPWR sky130_fd_sc_hd__decap_3
XFILLER_83_21 VGND VGND VPWR VPWR sky130_fd_sc_hd__decap_3
XFILLER_44_243 VGND VGND VPWR VPWR sky130_fd_sc_hd__decap_3
XFILLER_83_87 VGND VGND VPWR VPWR sky130_fd_sc_hd__fill_1
XTAP_TAPCELL_ROW_67_1055 VGND VPWR sky130_fd_sc_hd__tapvpwrvgnd_1
XFILLER_32_416 VGND VGND VPWR VPWR sky130_fd_sc_hd__decap_3
XFILLER_32_438 VGND VGND VPWR VPWR sky130_fd_sc_hd__decap_3
XFILLER_44_276 VGND VGND VPWR VPWR sky130_fd_sc_hd__decap_3
XFILLER_83_98 VGND VGND VPWR VPWR sky130_fd_sc_hd__decap_3
XTAP_TAPCELL_ROW_80_1211 VGND VPWR sky130_fd_sc_hd__tapvpwrvgnd_1
Xclkbuf_leaf_24_clk clkload0/A VGND VGND VPWR VPWR _6965_/CLK sky130_fd_sc_hd__clkbuf_16
XFILLER_40_460 VGND VGND VPWR VPWR sky130_fd_sc_hd__fill_1
XFILLER_80_9 VGND VGND VPWR VPWR sky130_fd_sc_hd__decap_3
XFILLER_8_100 VGND VGND VPWR VPWR sky130_fd_sc_hd__decap_3
XTAP_TAPCELL_ROW_30_617 VGND VPWR sky130_fd_sc_hd__tapvpwrvgnd_1
XTAP_TAPCELL_ROW_30_606 VGND VPWR sky130_fd_sc_hd__tapvpwrvgnd_1
XFILLER_9_612 VGND VGND VPWR VPWR sky130_fd_sc_hd__decap_3
XFILLER_12_195 VGND VGND VPWR VPWR sky130_fd_sc_hd__fill_1
XFILLER_40_493 VGND VGND VPWR VPWR sky130_fd_sc_hd__fill_1
XFILLER_8_133 VGND VGND VPWR VPWR sky130_fd_sc_hd__decap_3
XFILLER_8_155 VGND VGND VPWR VPWR sky130_fd_sc_hd__decap_3
XTAP_TAPCELL_ROW_10_374 VGND VPWR sky130_fd_sc_hd__tapvpwrvgnd_1
XFILLER_59_6 VGND VGND VPWR VPWR sky130_fd_sc_hd__decap_3
XTAP_TAPCELL_ROW_78_1184 VGND VPWR sky130_fd_sc_hd__tapvpwrvgnd_1
XFILLER_99_427 VGND VGND VPWR VPWR sky130_fd_sc_hd__decap_3
XFILLER_99_405 VGND VGND VPWR VPWR sky130_fd_sc_hd__fill_1
XFILLER_113_237 VGND VGND VPWR VPWR sky130_fd_sc_hd__decap_3
XFILLER_4_394 VGND VGND VPWR VPWR sky130_fd_sc_hd__decap_3
XTAP_TAPCELL_ROW_91_1340 VGND VPWR sky130_fd_sc_hd__tapvpwrvgnd_1
XFILLER_99_449 VGND VGND VPWR VPWR sky130_fd_sc_hd__decap_3
XFILLER_79_140 VGND VGND VPWR VPWR sky130_fd_sc_hd__decap_3
X_4180_ _7232_/Q _4469_/A3 _4503_/S _7045_/Q VGND VGND VPWR VPWR _4180_/X sky130_fd_sc_hd__a22o_2
XFILLER_94_110 VGND VGND VPWR VPWR sky130_fd_sc_hd__fill_1
XFILLER_95_611 VGND VGND VPWR VPWR sky130_fd_sc_hd__decap_3
XFILLER_55_508 VGND VGND VPWR VPWR sky130_fd_sc_hd__fill_2
XFILLER_94_132 VGND VGND VPWR VPWR sky130_fd_sc_hd__decap_3
XFILLER_95_644 VGND VGND VPWR VPWR sky130_fd_sc_hd__decap_3
XFILLER_48_571 VGND VGND VPWR VPWR sky130_fd_sc_hd__fill_1
XFILLER_94_176 VGND VGND VPWR VPWR sky130_fd_sc_hd__decap_3
XFILLER_95_688 VGND VGND VPWR VPWR sky130_fd_sc_hd__decap_3
XTAP_TAPCELL_ROW_38_706 VGND VPWR sky130_fd_sc_hd__tapvpwrvgnd_1
XFILLER_63_530 VGND VGND VPWR VPWR sky130_fd_sc_hd__decap_3
X_6821_ _6909_/CLK _6821_/D VGND VGND VPWR VPWR _6821_/Q sky130_fd_sc_hd__dfxtp_2
XFILLER_35_298 VGND VGND VPWR VPWR sky130_fd_sc_hd__decap_3
XFILLER_50_213 VGND VGND VPWR VPWR sky130_fd_sc_hd__decap_3
XTAP_TAPCELL_ROW_18_463 VGND VPWR sky130_fd_sc_hd__tapvpwrvgnd_1
XFILLER_50_246 VGND VGND VPWR VPWR sky130_fd_sc_hd__fill_2
Xclkbuf_leaf_15_clk clkload1/A VGND VGND VPWR VPWR _7372_/CLK sky130_fd_sc_hd__clkbuf_16
X_6752_ _6976_/CLK _6752_/D VGND VGND VPWR VPWR _6752_/Q sky130_fd_sc_hd__dfxtp_2
X_3964_ _7358_/Q _4507_/A0 _3964_/S VGND VGND VPWR VPWR _7358_/D sky130_fd_sc_hd__mux2_2
XFILLER_50_268 VGND VGND VPWR VPWR sky130_fd_sc_hd__decap_3
X_6683_ _6683_/A VGND VGND VPWR VPWR _6683_/Y sky130_fd_sc_hd__inv_2
X_5703_ _7357_/Q hold917/X _5721_/S VGND VGND VPWR VPWR _6701_/D sky130_fd_sc_hd__mux2_2
X_3895_ _3682_/A _3887_/X _3889_/X _3741_/X _3894_/X VGND VGND VPWR VPWR _3895_/X
+ sky130_fd_sc_hd__a221o_2
X_5634_ _5634_/A _5634_/B VGND VGND VPWR VPWR _7011_/D sky130_fd_sc_hd__and2_2
X_7304_ _7368_/CLK _7304_/D _6584_/Y VGND VGND VPWR VPWR _7304_/Q sky130_fd_sc_hd__dfrtp_2
XFILLER_2_309 VGND VGND VPWR VPWR sky130_fd_sc_hd__decap_3
X_7235_ _7363_/CLK _7235_/D _6515_/Y VGND VGND VPWR VPWR _7235_/Q sky130_fd_sc_hd__dfrtp_2
X_4447_ _4795_/A _4447_/B VGND VGND VPWR VPWR _4447_/Y sky130_fd_sc_hd__nor2_2
XFILLER_86_600 VGND VGND VPWR VPWR sky130_fd_sc_hd__decap_3
X_7166_ _7294_/CLK _7166_/D _6446_/Y VGND VGND VPWR VPWR _7166_/Q sky130_fd_sc_hd__dfrtp_2
XFILLER_100_410 VGND VGND VPWR VPWR sky130_fd_sc_hd__fill_1
XFILLER_58_302 VGND VGND VPWR VPWR sky130_fd_sc_hd__decap_3
XFILLER_58_324 VGND VGND VPWR VPWR sky130_fd_sc_hd__decap_3
XFILLER_86_633 VGND VGND VPWR VPWR sky130_fd_sc_hd__decap_3
X_4378_ _4243_/Y _4277_/Y _5032_/B _4377_/Y VGND VGND VPWR VPWR _4968_/A sky130_fd_sc_hd__a31o_4
XFILLER_100_421 VGND VGND VPWR VPWR sky130_fd_sc_hd__decap_3
XFILLER_86_666 VGND VGND VPWR VPWR sky130_fd_sc_hd__decap_3
X_7097_ clkload8/A _7097_/D _6377_/Y VGND VGND VPWR VPWR _7097_/Q sky130_fd_sc_hd__dfrtp_2
X_3329_ _6982_/Q _3340_/C VGND VGND VPWR VPWR _3329_/Y sky130_fd_sc_hd__nand2_2
XFILLER_37_36 VGND VGND VPWR VPWR sky130_fd_sc_hd__decap_3
XFILLER_58_368 VGND VGND VPWR VPWR sky130_fd_sc_hd__decap_3
XFILLER_85_154 VGND VGND VPWR VPWR sky130_fd_sc_hd__decap_3
XFILLER_26_221 VGND VGND VPWR VPWR sky130_fd_sc_hd__decap_3
XFILLER_37_69 VGND VGND VPWR VPWR sky130_fd_sc_hd__fill_1
XFILLER_66_390 VGND VGND VPWR VPWR sky130_fd_sc_hd__decap_3
XFILLER_73_327 VGND VGND VPWR VPWR sky130_fd_sc_hd__fill_1
XFILLER_85_187 VGND VGND VPWR VPWR sky130_fd_sc_hd__fill_1
XFILLER_14_416 VGND VGND VPWR VPWR sky130_fd_sc_hd__decap_3
XFILLER_41_202 VGND VGND VPWR VPWR sky130_fd_sc_hd__fill_1
XFILLER_53_24 VGND VGND VPWR VPWR sky130_fd_sc_hd__decap_3
XFILLER_41_268 VGND VGND VPWR VPWR sky130_fd_sc_hd__decap_3
XFILLER_10_677 VGND VGND VPWR VPWR sky130_fd_sc_hd__decap_3
XFILLER_108_521 VGND VGND VPWR VPWR sky130_fd_sc_hd__fill_2
XFILLER_5_125 VGND VGND VPWR VPWR sky130_fd_sc_hd__decap_3
XFILLER_5_158 VGND VGND VPWR VPWR sky130_fd_sc_hd__decap_3
XFILLER_5_169 VGND VGND VPWR VPWR sky130_fd_sc_hd__decap_3
XTAP_TAPCELL_ROW_114_1616 VGND VPWR sky130_fd_sc_hd__tapvpwrvgnd_1
XFILLER_108_598 VGND VGND VPWR VPWR sky130_fd_sc_hd__decap_3
XFILLER_1_331 VGND VGND VPWR VPWR sky130_fd_sc_hd__fill_2
XFILLER_78_54 VGND VGND VPWR VPWR sky130_fd_sc_hd__decap_3
XFILLER_96_408 VGND VGND VPWR VPWR sky130_fd_sc_hd__fill_2
XFILLER_96_419 VGND VGND VPWR VPWR sky130_fd_sc_hd__fill_1
XFILLER_1_364 VGND VGND VPWR VPWR sky130_fd_sc_hd__decap_3
XFILLER_49_313 VGND VGND VPWR VPWR sky130_fd_sc_hd__decap_3
XFILLER_77_600 VGND VGND VPWR VPWR sky130_fd_sc_hd__fill_1
XFILLER_77_633 VGND VGND VPWR VPWR sky130_fd_sc_hd__decap_3
XFILLER_103_281 VGND VGND VPWR VPWR sky130_fd_sc_hd__decap_3
XFILLER_49_346 VGND VGND VPWR VPWR sky130_fd_sc_hd__decap_3
XFILLER_77_666 VGND VGND VPWR VPWR sky130_fd_sc_hd__decap_3
XFILLER_76_165 VGND VGND VPWR VPWR sky130_fd_sc_hd__decap_3
XFILLER_77_688 VGND VGND VPWR VPWR sky130_fd_sc_hd__decap_3
XFILLER_91_102 VGND VGND VPWR VPWR sky130_fd_sc_hd__decap_3
XFILLER_17_210 VGND VGND VPWR VPWR sky130_fd_sc_hd__decap_3
XFILLER_91_113 VGND VGND VPWR VPWR sky130_fd_sc_hd__decap_3
XFILLER_17_243 VGND VGND VPWR VPWR sky130_fd_sc_hd__decap_3
XFILLER_92_669 VGND VGND VPWR VPWR sky130_fd_sc_hd__decap_3
XFILLER_94_97 VGND VGND VPWR VPWR sky130_fd_sc_hd__decap_3
XFILLER_72_360 VGND VGND VPWR VPWR sky130_fd_sc_hd__decap_3
XFILLER_72_393 VGND VGND VPWR VPWR sky130_fd_sc_hd__decap_3
XTAP_TAPCELL_ROW_15_433 VGND VPWR sky130_fd_sc_hd__tapvpwrvgnd_1
XFILLER_32_268 VGND VGND VPWR VPWR sky130_fd_sc_hd__decap_3
XTAP_TAPCELL_ROW_43_764 VGND VPWR sky130_fd_sc_hd__tapvpwrvgnd_1
XFILLER_40_290 VGND VGND VPWR VPWR sky130_fd_sc_hd__decap_3
X_3680_ _3677_/Y _3902_/A2 _3925_/B1 _3679_/Y VGND VGND VPWR VPWR _3680_/X sky130_fd_sc_hd__a22o_2
XFILLER_9_497 VGND VGND VPWR VPWR sky130_fd_sc_hd__decap_3
X_5350_ _5350_/A0 _5131_/X _5358_/S VGND VGND VPWR VPWR _7156_/D sky130_fd_sc_hd__mux2_2
X_4301_ _7352_/Q _4338_/B1 _4339_/B1 _7160_/Q _4300_/X VGND VGND VPWR VPWR _4301_/X
+ sky130_fd_sc_hd__a221o_2
XFILLER_114_557 VGND VGND VPWR VPWR sky130_fd_sc_hd__decap_3
X_7020_ _7363_/CLK _7020_/D _6300_/Y VGND VGND VPWR VPWR _7020_/Q sky130_fd_sc_hd__dfrtp_2
X_4232_ _4228_/X _4231_/X _4327_/A VGND VGND VPWR VPWR _4628_/A sky130_fd_sc_hd__o21a_2
XFILLER_99_257 VGND VGND VPWR VPWR sky130_fd_sc_hd__fill_1
XFILLER_4_62 VGND VGND VPWR VPWR sky130_fd_sc_hd__decap_3
Xclkbuf_leaf_4_clk clkbuf_leaf_4_clk/A VGND VGND VPWR VPWR _7265_/CLK sky130_fd_sc_hd__clkbuf_16
XFILLER_68_666 VGND VGND VPWR VPWR sky130_fd_sc_hd__decap_3
X_4163_ _7073_/Q _4265_/B _4205_/A VGND VGND VPWR VPWR _4203_/B sky130_fd_sc_hd__o21a_2
XFILLER_67_143 VGND VGND VPWR VPWR sky130_fd_sc_hd__decap_3
XFILLER_67_165 VGND VGND VPWR VPWR sky130_fd_sc_hd__decap_3
XFILLER_82_102 VGND VGND VPWR VPWR sky130_fd_sc_hd__decap_3
XFILLER_95_452 VGND VGND VPWR VPWR sky130_fd_sc_hd__decap_3
X_4094_ _4095_/A _4210_/B VGND VGND VPWR VPWR _4096_/A sky130_fd_sc_hd__or2_2
XFILLER_55_327 VGND VGND VPWR VPWR sky130_fd_sc_hd__decap_3
XFILLER_67_198 VGND VGND VPWR VPWR sky130_fd_sc_hd__fill_1
XFILLER_83_647 VGND VGND VPWR VPWR sky130_fd_sc_hd__decap_3
XFILLER_23_202 VGND VGND VPWR VPWR sky130_fd_sc_hd__decap_3
XFILLER_91_691 VGND VGND VPWR VPWR sky130_fd_sc_hd__fill_1
XFILLER_23_246 VGND VGND VPWR VPWR sky130_fd_sc_hd__decap_3
XFILLER_63_393 VGND VGND VPWR VPWR sky130_fd_sc_hd__decap_3
Xplace382 _3429_/A VGND VGND VPWR VPWR _3392_/A sky130_fd_sc_hd__buf_2
Xplace371 _4799_/A VGND VGND VPWR VPWR _4832_/A sky130_fd_sc_hd__buf_2
Xplace360 _4352_/B1 VGND VGND VPWR VPWR _4436_/B1 sky130_fd_sc_hd__buf_2
X_6804_ _7005_/CLK _6804_/D VGND VGND VPWR VPWR _6804_/Q sky130_fd_sc_hd__dfxtp_2
X_4996_ _4832_/A _5657_/D _3817_/X _3346_/A VGND VGND VPWR VPWR _4996_/X sky130_fd_sc_hd__o211a_2
XFILLER_23_27 VGND VGND VPWR VPWR sky130_fd_sc_hd__decap_3
XFILLER_51_599 VGND VGND VPWR VPWR sky130_fd_sc_hd__decap_3
Xplace393 _7412_/A VGND VGND VPWR VPWR _5315_/S sky130_fd_sc_hd__buf_2
X_6735_ _6909_/CLK _6735_/D VGND VGND VPWR VPWR _6735_/Q sky130_fd_sc_hd__dfxtp_2
X_3947_ _7366_/Q _4491_/A0 _3958_/S VGND VGND VPWR VPWR _7366_/D sky130_fd_sc_hd__mux2_2
X_6666_ _6670_/A VGND VGND VPWR VPWR _6666_/Y sky130_fd_sc_hd__inv_2
X_3878_ _6729_/Q _3884_/B1 _3888_/B1 _6741_/Q VGND VGND VPWR VPWR _3878_/X sky130_fd_sc_hd__a22o_2
X_6597_ _6635_/A VGND VGND VPWR VPWR _6597_/Y sky130_fd_sc_hd__inv_2
X_5617_ _5617_/A _5634_/B VGND VGND VPWR VPWR _7019_/D sky130_fd_sc_hd__and2_2
XFILLER_2_106 VGND VGND VPWR VPWR sky130_fd_sc_hd__decap_3
XFILLER_105_546 VGND VGND VPWR VPWR sky130_fd_sc_hd__decap_3
XFILLER_2_139 VGND VGND VPWR VPWR sky130_fd_sc_hd__fill_1
X_7218_ _7384_/CLK _7218_/D _6498_/Y VGND VGND VPWR VPWR _7218_/Q sky130_fd_sc_hd__dfrtp_2
XFILLER_48_24 VGND VGND VPWR VPWR sky130_fd_sc_hd__decap_3
XFILLER_59_611 VGND VGND VPWR VPWR sky130_fd_sc_hd__decap_3
XFILLER_78_419 VGND VGND VPWR VPWR sky130_fd_sc_hd__fill_1
XFILLER_58_132 VGND VGND VPWR VPWR sky130_fd_sc_hd__decap_3
XFILLER_59_644 VGND VGND VPWR VPWR sky130_fd_sc_hd__decap_3
X_7149_ _7310_/CLK _7149_/D _6429_/Y VGND VGND VPWR VPWR _7149_/Q sky130_fd_sc_hd__dfrtp_2
XFILLER_98_290 VGND VGND VPWR VPWR sky130_fd_sc_hd__decap_3
XFILLER_100_262 VGND VGND VPWR VPWR sky130_fd_sc_hd__decap_3
XFILLER_58_165 VGND VGND VPWR VPWR sky130_fd_sc_hd__decap_3
XFILLER_59_688 VGND VGND VPWR VPWR sky130_fd_sc_hd__decap_3
XFILLER_86_474 VGND VGND VPWR VPWR sky130_fd_sc_hd__fill_2
XFILLER_100_273 VGND VGND VPWR VPWR sky130_fd_sc_hd__decap_3
XFILLER_104_63 VGND VGND VPWR VPWR sky130_fd_sc_hd__fill_2
XFILLER_64_12 VGND VGND VPWR VPWR sky130_fd_sc_hd__decap_3
XFILLER_73_102 VGND VGND VPWR VPWR sky130_fd_sc_hd__decap_3
XFILLER_73_113 VGND VGND VPWR VPWR sky130_fd_sc_hd__decap_3
XPHY_EDGE_ROW_100_Left_217 VGND VGND VPWR VPWR sky130_fd_sc_hd__decap_3
XFILLER_104_74 VGND VGND VPWR VPWR sky130_fd_sc_hd__decap_3
XFILLER_104_85 VGND VGND VPWR VPWR sky130_fd_sc_hd__decap_3
XFILLER_39_390 VGND VGND VPWR VPWR sky130_fd_sc_hd__fill_2
XFILLER_64_34 VGND VGND VPWR VPWR sky130_fd_sc_hd__decap_3
XFILLER_74_669 VGND VGND VPWR VPWR sky130_fd_sc_hd__decap_3
XFILLER_27_585 VGND VGND VPWR VPWR sky130_fd_sc_hd__decap_3
XFILLER_61_319 VGND VGND VPWR VPWR sky130_fd_sc_hd__decap_3
XFILLER_73_179 VGND VGND VPWR VPWR sky130_fd_sc_hd__decap_3
XTAP_TAPCELL_ROW_64_1014 VGND VPWR sky130_fd_sc_hd__tapvpwrvgnd_1
XFILLER_14_224 VGND VGND VPWR VPWR sky130_fd_sc_hd__decap_3
XFILLER_42_533 VGND VGND VPWR VPWR sky130_fd_sc_hd__decap_3
XTAP_TAPCELL_ROW_64_1025 VGND VPWR sky130_fd_sc_hd__tapvpwrvgnd_1
XFILLER_9_18 VGND VGND VPWR VPWR sky130_fd_sc_hd__decap_3
XFILLER_14_268 VGND VGND VPWR VPWR sky130_fd_sc_hd__decap_3
Xfanout50 fanout51/X VGND VGND VPWR VPWR _6388_/A sky130_fd_sc_hd__buf_2
Xfanout61 _6587_/A VGND VGND VPWR VPWR _6584_/A sky130_fd_sc_hd__buf_2
Xfanout72 _6280_/A VGND VGND VPWR VPWR fanout72/X sky130_fd_sc_hd__clkdlybuf4s25_1
XTAP_TAPCELL_ROW_40_734 VGND VPWR sky130_fd_sc_hd__tapvpwrvgnd_1
XFILLER_13_60 VGND VGND VPWR VPWR sky130_fd_sc_hd__decap_3
XFILLER_80_77 VGND VGND VPWR VPWR sky130_fd_sc_hd__decap_3
XFILLER_80_88 VGND VGND VPWR VPWR sky130_fd_sc_hd__fill_2
XFILLER_6_445 VGND VGND VPWR VPWR sky130_fd_sc_hd__decap_3
XTAP_TAPCELL_ROW_20_491 VGND VPWR sky130_fd_sc_hd__tapvpwrvgnd_1
XFILLER_89_53 VGND VGND VPWR VPWR sky130_fd_sc_hd__decap_3
XFILLER_2_651 VGND VGND VPWR VPWR sky130_fd_sc_hd__decap_3
XFILLER_43_9 VGND VGND VPWR VPWR sky130_fd_sc_hd__decap_3
XTAP_TAPCELL_ROW_75_1154 VGND VPWR sky130_fd_sc_hd__tapvpwrvgnd_1
XFILLER_111_516 VGND VGND VPWR VPWR sky130_fd_sc_hd__decap_3
XFILLER_1_161 VGND VGND VPWR VPWR sky130_fd_sc_hd__decap_3
XFILLER_2_684 VGND VGND VPWR VPWR sky130_fd_sc_hd__decap_3
XFILLER_49_165 VGND VGND VPWR VPWR sky130_fd_sc_hd__decap_3
XFILLER_65_603 VGND VGND VPWR VPWR sky130_fd_sc_hd__decap_3
XFILLER_77_452 VGND VGND VPWR VPWR sky130_fd_sc_hd__decap_3
XFILLER_49_187 VGND VGND VPWR VPWR sky130_fd_sc_hd__fill_1
XFILLER_64_124 VGND VGND VPWR VPWR sky130_fd_sc_hd__decap_3
XFILLER_65_647 VGND VGND VPWR VPWR sky130_fd_sc_hd__decap_3
XFILLER_92_433 VGND VGND VPWR VPWR sky130_fd_sc_hd__decap_3
XTAP_TAPCELL_ROW_48_823 VGND VPWR sky130_fd_sc_hd__tapvpwrvgnd_1
XFILLER_18_530 VGND VGND VPWR VPWR sky130_fd_sc_hd__fill_2
XFILLER_80_606 VGND VGND VPWR VPWR sky130_fd_sc_hd__decap_3
XFILLER_92_466 VGND VGND VPWR VPWR sky130_fd_sc_hd__decap_3
XFILLER_92_477 VGND VGND VPWR VPWR sky130_fd_sc_hd__decap_3
Xclkbuf_3_7__f_clk clkbuf_0_clk/X VGND VGND VPWR VPWR clkload1/A sky130_fd_sc_hd__clkbuf_16
XFILLER_18_585 VGND VGND VPWR VPWR sky130_fd_sc_hd__decap_3
XFILLER_45_360 VGND VGND VPWR VPWR sky130_fd_sc_hd__decap_3
XFILLER_80_639 VGND VGND VPWR VPWR sky130_fd_sc_hd__decap_3
X_4850_ _4142_/X _4849_/Y _4633_/A VGND VGND VPWR VPWR _4850_/Y sky130_fd_sc_hd__o21ai_2
XTAP_TAPCELL_ROW_86_1283 VGND VPWR sky130_fd_sc_hd__tapvpwrvgnd_1
XTAP_TAPCELL_ROW_28_591 VGND VPWR sky130_fd_sc_hd__tapvpwrvgnd_1
XFILLER_60_352 VGND VGND VPWR VPWR sky130_fd_sc_hd__fill_2
X_3801_ _3735_/X _3798_/X _3800_/X _3714_/X VGND VGND VPWR VPWR _3801_/X sky130_fd_sc_hd__a22o_2
XFILLER_60_385 VGND VGND VPWR VPWR sky130_fd_sc_hd__decap_3
X_6520_ _6616_/A VGND VGND VPWR VPWR _6520_/Y sky130_fd_sc_hd__inv_2
X_4781_ _4444_/X _4780_/Y _4413_/A VGND VGND VPWR VPWR _4781_/X sky130_fd_sc_hd__o21a_2
XFILLER_13_290 VGND VGND VPWR VPWR sky130_fd_sc_hd__decap_3
X_3732_ _6776_/Q _3884_/A2 _3883_/A2 _6764_/Q _3731_/X VGND VGND VPWR VPWR _3732_/X
+ sky130_fd_sc_hd__a221o_2
Xclkload20 _7265_/CLK VGND VGND VPWR VPWR clkload20/Y sky130_fd_sc_hd__bufinv_16
X_6451_ _6483_/A VGND VGND VPWR VPWR _6451_/Y sky130_fd_sc_hd__inv_2
Xclkload31 _7390_/CLK VGND VGND VPWR VPWR clkload31/X sky130_fd_sc_hd__clkbuf_16
X_6382_ _6539_/A VGND VGND VPWR VPWR _6382_/Y sky130_fd_sc_hd__inv_2
X_5402_ _5402_/A0 _5027_/X _5429_/S VGND VGND VPWR VPWR _7132_/D sky130_fd_sc_hd__mux2_2
XFILLER_114_321 VGND VGND VPWR VPWR sky130_fd_sc_hd__decap_3
X_5333_ _5333_/A0 _5027_/X _5360_/S VGND VGND VPWR VPWR _7164_/D sky130_fd_sc_hd__mux2_2
X_3594_ _4292_/A _3594_/B VGND VGND VPWR VPWR _3594_/Y sky130_fd_sc_hd__nor2_2
XFILLER_114_354 VGND VGND VPWR VPWR sky130_fd_sc_hd__decap_3
X_5264_ _5264_/A0 _4997_/X _5274_/S VGND VGND VPWR VPWR _7198_/D sky130_fd_sc_hd__mux2_2
XFILLER_102_549 VGND VGND VPWR VPWR sky130_fd_sc_hd__decap_3
XFILLER_68_430 VGND VGND VPWR VPWR sky130_fd_sc_hd__fill_1
XFILLER_68_441 VGND VGND VPWR VPWR sky130_fd_sc_hd__decap_3
X_7003_ _7406_/CLK _7003_/D _6283_/Y VGND VGND VPWR VPWR _7003_/Q sky130_fd_sc_hd__dfrtp_2
X_4215_ _7260_/Q _4356_/A2 _4212_/X _4214_/X VGND VGND VPWR VPWR _4371_/A sky130_fd_sc_hd__a211o_2
XFILLER_110_560 VGND VGND VPWR VPWR sky130_fd_sc_hd__decap_3
X_4146_ _7234_/Q _4349_/B1 _4420_/B1 _7138_/Q VGND VGND VPWR VPWR _4146_/X sky130_fd_sc_hd__a22o_2
XFILLER_18_27 VGND VGND VPWR VPWR sky130_fd_sc_hd__fill_1
XFILLER_28_338 VGND VGND VPWR VPWR sky130_fd_sc_hd__decap_3
XFILLER_55_113 VGND VGND VPWR VPWR sky130_fd_sc_hd__fill_2
XFILLER_55_124 VGND VGND VPWR VPWR sky130_fd_sc_hd__decap_3
XFILLER_56_625 VGND VGND VPWR VPWR sky130_fd_sc_hd__decap_3
XFILLER_83_411 VGND VGND VPWR VPWR sky130_fd_sc_hd__fill_2
XFILLER_83_433 VGND VGND VPWR VPWR sky130_fd_sc_hd__decap_3
XFILLER_43_308 VGND VGND VPWR VPWR sky130_fd_sc_hd__decap_3
XFILLER_83_455 VGND VGND VPWR VPWR sky130_fd_sc_hd__decap_3
XFILLER_83_466 VGND VGND VPWR VPWR sky130_fd_sc_hd__decap_3
X_4077_ _7243_/Q _4433_/B _4434_/A2 _7115_/Q _4076_/X VGND VGND VPWR VPWR _4077_/X
+ sky130_fd_sc_hd__a221o_2
XFILLER_83_477 VGND VGND VPWR VPWR sky130_fd_sc_hd__decap_3
XFILLER_34_15 VGND VGND VPWR VPWR sky130_fd_sc_hd__decap_3
XFILLER_70_127 VGND VGND VPWR VPWR sky130_fd_sc_hd__decap_3
XFILLER_51_352 VGND VGND VPWR VPWR sky130_fd_sc_hd__decap_3
XFILLER_51_396 VGND VGND VPWR VPWR sky130_fd_sc_hd__decap_3
X_4979_ _4979_/A0 _4978_/X _5028_/S VGND VGND VPWR VPWR _7263_/D sky130_fd_sc_hd__mux2_2
XFILLER_11_249 VGND VGND VPWR VPWR sky130_fd_sc_hd__decap_3
Xclkload3 clkload3/A VGND VGND VPWR VPWR clkload3/X sky130_fd_sc_hd__clkbuf_1
X_6718_ _7374_/CLK _6718_/D VGND VGND VPWR VPWR _6718_/Q sky130_fd_sc_hd__dfxtp_2
XFILLER_109_137 VGND VGND VPWR VPWR sky130_fd_sc_hd__decap_3
XFILLER_50_58 VGND VGND VPWR VPWR sky130_fd_sc_hd__decap_3
X_6649_ _6651_/A VGND VGND VPWR VPWR _6649_/Y sky130_fd_sc_hd__inv_2
XFILLER_3_426 VGND VGND VPWR VPWR sky130_fd_sc_hd__decap_3
XFILLER_105_332 VGND VGND VPWR VPWR sky130_fd_sc_hd__decap_3
XFILLER_105_354 VGND VGND VPWR VPWR sky130_fd_sc_hd__decap_3
XFILLER_59_12 VGND VGND VPWR VPWR sky130_fd_sc_hd__decap_3
XFILLER_105_365 VGND VGND VPWR VPWR sky130_fd_sc_hd__decap_3
XFILLER_59_45 VGND VGND VPWR VPWR sky130_fd_sc_hd__decap_3
XFILLER_59_78 VGND VGND VPWR VPWR sky130_fd_sc_hd__decap_3
XFILLER_101_571 VGND VGND VPWR VPWR sky130_fd_sc_hd__decap_3
XFILLER_115_84 VGND VGND VPWR VPWR sky130_fd_sc_hd__decap_3
XFILLER_47_647 VGND VGND VPWR VPWR sky130_fd_sc_hd__decap_3
XTAP_TAPCELL_ROW_70_1095 VGND VPWR sky130_fd_sc_hd__tapvpwrvgnd_1
XTAP_TAPCELL_ROW_109_1559 VGND VPWR sky130_fd_sc_hd__tapvpwrvgnd_1
XFILLER_46_168 VGND VGND VPWR VPWR sky130_fd_sc_hd__decap_3
XFILLER_61_116 VGND VGND VPWR VPWR sky130_fd_sc_hd__fill_2
XFILLER_62_628 VGND VGND VPWR VPWR sky130_fd_sc_hd__decap_3
XFILLER_27_393 VGND VGND VPWR VPWR sky130_fd_sc_hd__fill_2
XFILLER_55_691 VGND VGND VPWR VPWR sky130_fd_sc_hd__fill_1
XFILLER_91_21 VGND VGND VPWR VPWR sky130_fd_sc_hd__decap_3
XFILLER_15_555 VGND VGND VPWR VPWR sky130_fd_sc_hd__decap_3
XFILLER_70_672 VGND VGND VPWR VPWR sky130_fd_sc_hd__decap_3
XTAP_TAPCELL_ROW_25_550 VGND VPWR sky130_fd_sc_hd__tapvpwrvgnd_1
XFILLER_42_385 VGND VGND VPWR VPWR sky130_fd_sc_hd__decap_3
XFILLER_91_87 VGND VGND VPWR VPWR sky130_fd_sc_hd__decap_3
XTAP_TAPCELL_ROW_53_892 VGND VPWR sky130_fd_sc_hd__tapvpwrvgnd_1
XFILLER_24_70 VGND VGND VPWR VPWR sky130_fd_sc_hd__decap_3
XFILLER_6_231 VGND VGND VPWR VPWR sky130_fd_sc_hd__decap_3
XFILLER_6_253 VGND VGND VPWR VPWR sky130_fd_sc_hd__fill_1
XFILLER_109_671 VGND VGND VPWR VPWR sky130_fd_sc_hd__fill_1
XFILLER_109_682 VGND VGND VPWR VPWR sky130_fd_sc_hd__decap_3
XFILLER_40_80 VGND VGND VPWR VPWR sky130_fd_sc_hd__decap_3
XFILLER_108_192 VGND VGND VPWR VPWR sky130_fd_sc_hd__decap_3
XFILLER_111_302 VGND VGND VPWR VPWR sky130_fd_sc_hd__fill_2
XFILLER_69_205 VGND VGND VPWR VPWR sky130_fd_sc_hd__decap_3
XFILLER_97_514 VGND VGND VPWR VPWR sky130_fd_sc_hd__decap_3
XFILLER_69_249 VGND VGND VPWR VPWR sky130_fd_sc_hd__decap_3
XFILLER_111_379 VGND VGND VPWR VPWR sky130_fd_sc_hd__decap_3
XFILLER_38_614 VGND VGND VPWR VPWR sky130_fd_sc_hd__decap_3
XFILLER_1_41 VGND VGND VPWR VPWR sky130_fd_sc_hd__decap_3
XFILLER_37_102 VGND VGND VPWR VPWR sky130_fd_sc_hd__decap_3
XFILLER_37_113 VGND VGND VPWR VPWR sky130_fd_sc_hd__decap_3
XFILLER_77_260 VGND VGND VPWR VPWR sky130_fd_sc_hd__decap_3
XTAP_TAPCELL_ROW_88_1312 VGND VPWR sky130_fd_sc_hd__tapvpwrvgnd_1
XFILLER_1_63 VGND VGND VPWR VPWR sky130_fd_sc_hd__decap_3
XFILLER_38_669 VGND VGND VPWR VPWR sky130_fd_sc_hd__decap_3
XFILLER_18_371 VGND VGND VPWR VPWR sky130_fd_sc_hd__decap_3
XFILLER_1_96 VGND VGND VPWR VPWR sky130_fd_sc_hd__decap_3
XFILLER_25_319 VGND VGND VPWR VPWR sky130_fd_sc_hd__decap_3
XFILLER_53_617 VGND VGND VPWR VPWR sky130_fd_sc_hd__decap_3
XFILLER_65_477 VGND VGND VPWR VPWR sky130_fd_sc_hd__decap_3
XFILLER_18_382 VGND VGND VPWR VPWR sky130_fd_sc_hd__fill_1
XFILLER_80_436 VGND VGND VPWR VPWR sky130_fd_sc_hd__decap_3
XFILLER_61_650 VGND VGND VPWR VPWR sky130_fd_sc_hd__decap_3
XFILLER_80_469 VGND VGND VPWR VPWR sky130_fd_sc_hd__decap_3
XFILLER_21_547 VGND VGND VPWR VPWR sky130_fd_sc_hd__fill_2
XFILLER_33_396 VGND VGND VPWR VPWR sky130_fd_sc_hd__decap_3
XFILLER_60_171 VGND VGND VPWR VPWR sky130_fd_sc_hd__decap_3
X_4833_ _7001_/Q _4687_/B _4983_/A VGND VGND VPWR VPWR _4834_/B sky130_fd_sc_hd__o21ai_2
XFILLER_21_558 VGND VGND VPWR VPWR sky130_fd_sc_hd__fill_2
XFILLER_60_193 VGND VGND VPWR VPWR sky130_fd_sc_hd__decap_3
X_4764_ _4938_/A _4764_/B VGND VGND VPWR VPWR _4765_/A sky130_fd_sc_hd__nor2_2
X_6503_ _6570_/A VGND VGND VPWR VPWR _6503_/Y sky130_fd_sc_hd__inv_2
XTAP_TAPCELL_ROW_99_1441 VGND VPWR sky130_fd_sc_hd__tapvpwrvgnd_1
X_6434_ _6570_/A VGND VGND VPWR VPWR _6434_/Y sky130_fd_sc_hd__inv_2
X_4695_ _7008_/Q _4728_/A _4694_/Y _4909_/A VGND VGND VPWR VPWR _4695_/X sky130_fd_sc_hd__a211o_2
XFILLER_115_641 VGND VGND VPWR VPWR sky130_fd_sc_hd__decap_3
X_6365_ _6366_/A VGND VGND VPWR VPWR _6365_/Y sky130_fd_sc_hd__inv_2
X_3577_ _7060_/Q _3577_/B VGND VGND VPWR VPWR _3591_/C sky130_fd_sc_hd__nor2_2
XFILLER_0_418 VGND VGND VPWR VPWR sky130_fd_sc_hd__fill_2
XFILLER_114_162 VGND VGND VPWR VPWR sky130_fd_sc_hd__decap_3
X_6296_ _6539_/A VGND VGND VPWR VPWR _6296_/Y sky130_fd_sc_hd__inv_2
XFILLER_102_324 VGND VGND VPWR VPWR sky130_fd_sc_hd__decap_3
XFILLER_114_195 VGND VGND VPWR VPWR sky130_fd_sc_hd__fill_1
XFILLER_29_15 VGND VGND VPWR VPWR sky130_fd_sc_hd__decap_3
X_5247_ _5247_/A0 _4864_/X _5262_/S VGND VGND VPWR VPWR _7206_/D sky130_fd_sc_hd__mux2_2
XFILLER_102_379 VGND VGND VPWR VPWR sky130_fd_sc_hd__decap_3
XFILLER_56_411 VGND VGND VPWR VPWR sky130_fd_sc_hd__decap_3
XFILLER_44_606 VGND VGND VPWR VPWR sky130_fd_sc_hd__fill_1
XFILLER_56_455 VGND VGND VPWR VPWR sky130_fd_sc_hd__decap_3
XFILLER_83_241 VGND VGND VPWR VPWR sky130_fd_sc_hd__fill_1
X_4129_ _7299_/Q _4501_/S _4419_/B1 _7363_/Q _4248_/A VGND VGND VPWR VPWR _4129_/X
+ sky130_fd_sc_hd__a221o_2
XFILLER_43_116 VGND VGND VPWR VPWR sky130_fd_sc_hd__decap_3
XFILLER_56_477 VGND VGND VPWR VPWR sky130_fd_sc_hd__decap_3
XFILLER_71_414 VGND VGND VPWR VPWR sky130_fd_sc_hd__decap_3
XTAP_TAPCELL_ROW_3_289 VGND VPWR sky130_fd_sc_hd__tapvpwrvgnd_1
XFILLER_37_691 VGND VGND VPWR VPWR sky130_fd_sc_hd__fill_1
XFILLER_71_458 VGND VGND VPWR VPWR sky130_fd_sc_hd__decap_3
XFILLER_101_20 VGND VGND VPWR VPWR sky130_fd_sc_hd__decap_3
XFILLER_24_363 VGND VGND VPWR VPWR sky130_fd_sc_hd__fill_1
XFILLER_52_672 VGND VGND VPWR VPWR sky130_fd_sc_hd__decap_3
XFILLER_101_53 VGND VGND VPWR VPWR sky130_fd_sc_hd__decap_3
XFILLER_24_385 VGND VGND VPWR VPWR sky130_fd_sc_hd__decap_3
XFILLER_61_24 VGND VGND VPWR VPWR sky130_fd_sc_hd__decap_3
XFILLER_101_86 VGND VGND VPWR VPWR sky130_fd_sc_hd__decap_3
XTAP_TAPCELL_ROW_50_851 VGND VPWR sky130_fd_sc_hd__tapvpwrvgnd_1
XTAP_TAPCELL_ROW_22_520 VGND VPWR sky130_fd_sc_hd__tapvpwrvgnd_1
XFILLER_106_630 VGND VGND VPWR VPWR sky130_fd_sc_hd__decap_3
XFILLER_3_234 VGND VGND VPWR VPWR sky130_fd_sc_hd__decap_3
XFILLER_105_151 VGND VGND VPWR VPWR sky130_fd_sc_hd__decap_3
XFILLER_106_663 VGND VGND VPWR VPWR sky130_fd_sc_hd__decap_3
XFILLER_10_50 VGND VGND VPWR VPWR sky130_fd_sc_hd__decap_3
XFILLER_3_267 VGND VGND VPWR VPWR sky130_fd_sc_hd__fill_2
XFILLER_3_278 VGND VGND VPWR VPWR sky130_fd_sc_hd__fill_2
XTAP_TAPCELL_ROW_72_1113 VGND VPWR sky130_fd_sc_hd__tapvpwrvgnd_1
XFILLER_10_83 VGND VGND VPWR VPWR sky130_fd_sc_hd__fill_1
XFILLER_10_94 VGND VGND VPWR VPWR sky130_fd_sc_hd__decap_3
XFILLER_19_113 VGND VGND VPWR VPWR sky130_fd_sc_hd__decap_3
XFILLER_47_411 VGND VGND VPWR VPWR sky130_fd_sc_hd__decap_3
XFILLER_59_271 VGND VGND VPWR VPWR sky130_fd_sc_hd__decap_3
XFILLER_66_219 VGND VGND VPWR VPWR sky130_fd_sc_hd__decap_3
XFILLER_86_76 VGND VGND VPWR VPWR sky130_fd_sc_hd__decap_3
XFILLER_94_539 VGND VGND VPWR VPWR sky130_fd_sc_hd__decap_3
XFILLER_19_92 VGND VGND VPWR VPWR sky130_fd_sc_hd__decap_3
XFILLER_47_455 VGND VGND VPWR VPWR sky130_fd_sc_hd__fill_1
XTAP_TAPCELL_ROW_58_951 VGND VPWR sky130_fd_sc_hd__tapvpwrvgnd_1
XFILLER_35_617 VGND VGND VPWR VPWR sky130_fd_sc_hd__decap_3
XFILLER_62_414 VGND VGND VPWR VPWR sky130_fd_sc_hd__decap_3
XFILLER_34_127 VGND VGND VPWR VPWR sky130_fd_sc_hd__decap_3
XFILLER_62_447 VGND VGND VPWR VPWR sky130_fd_sc_hd__decap_3
XFILLER_50_609 VGND VGND VPWR VPWR sky130_fd_sc_hd__decap_3
XTAP_TAPCELL_ROW_83_1253 VGND VPWR sky130_fd_sc_hd__tapvpwrvgnd_1
XTAP_TAPCELL_ROW_83_1242 VGND VPWR sky130_fd_sc_hd__tapvpwrvgnd_1
XFILLER_15_396 VGND VGND VPWR VPWR sky130_fd_sc_hd__decap_3
XFILLER_70_480 VGND VGND VPWR VPWR sky130_fd_sc_hd__decap_3
XFILLER_30_333 VGND VGND VPWR VPWR sky130_fd_sc_hd__decap_3
XFILLER_89_6 VGND VGND VPWR VPWR sky130_fd_sc_hd__decap_3
XFILLER_30_388 VGND VGND VPWR VPWR sky130_fd_sc_hd__decap_3
XFILLER_11_591 VGND VGND VPWR VPWR sky130_fd_sc_hd__decap_3
X_3500_ _4460_/A _4460_/B _3541_/B VGND VGND VPWR VPWR _3500_/Y sky130_fd_sc_hd__a21oi_2
XFILLER_116_405 VGND VGND VPWR VPWR sky130_fd_sc_hd__fill_1
XFILLER_116_427 VGND VGND VPWR VPWR sky130_fd_sc_hd__decap_3
X_4480_ _4480_/A0 _7307_/Q _4488_/S VGND VGND VPWR VPWR _7339_/D sky130_fd_sc_hd__mux2_2
XFILLER_116_449 VGND VGND VPWR VPWR sky130_fd_sc_hd__decap_3
X_3362_ _3362_/A _4697_/A _3561_/A VGND VGND VPWR VPWR _3362_/X sky130_fd_sc_hd__or3b_2
XTAP_TAPCELL_ROW_94_1382 VGND VPWR sky130_fd_sc_hd__tapvpwrvgnd_1
XFILLER_112_622 VGND VGND VPWR VPWR sky130_fd_sc_hd__decap_3
XFILLER_97_311 VGND VGND VPWR VPWR sky130_fd_sc_hd__decap_3
X_5101_ _5101_/A _5101_/B VGND VGND VPWR VPWR _5101_/Y sky130_fd_sc_hd__nor2_2
XFILLER_111_143 VGND VGND VPWR VPWR sky130_fd_sc_hd__decap_3
XFILLER_112_666 VGND VGND VPWR VPWR sky130_fd_sc_hd__decap_3
Xhold1207 _7182_/Q VGND VGND VPWR VPWR _5296_/A0 sky130_fd_sc_hd__dlygate4sd3_1
XFILLER_111_187 VGND VGND VPWR VPWR sky130_fd_sc_hd__decap_3
Xhold1218 _7147_/Q VGND VGND VPWR VPWR _5371_/A0 sky130_fd_sc_hd__dlygate4sd3_1
Xhold1229 _7227_/Q VGND VGND VPWR VPWR _5203_/A sky130_fd_sc_hd__dlygate4sd3_1
X_5032_ _5032_/A _5032_/B VGND VGND VPWR VPWR _5032_/Y sky130_fd_sc_hd__xnor2_2
XFILLER_93_550 VGND VGND VPWR VPWR sky130_fd_sc_hd__decap_3
XFILLER_26_639 VGND VGND VPWR VPWR sky130_fd_sc_hd__decap_3
XFILLER_53_414 VGND VGND VPWR VPWR sky130_fd_sc_hd__decap_3
XFILLER_93_561 VGND VGND VPWR VPWR sky130_fd_sc_hd__decap_3
XFILLER_53_436 VGND VGND VPWR VPWR sky130_fd_sc_hd__decap_3
X_6983_ _7266_/CLK _6983_/D _6263_/Y VGND VGND VPWR VPWR _6983_/Q sky130_fd_sc_hd__dfrtp_2
XTAP_TAPCELL_ROW_0_248 VGND VPWR sky130_fd_sc_hd__tapvpwrvgnd_1
XTAP_TAPCELL_ROW_0_237 VGND VPWR sky130_fd_sc_hd__tapvpwrvgnd_1
XFILLER_15_39 VGND VGND VPWR VPWR sky130_fd_sc_hd__decap_3
XFILLER_40_108 VGND VGND VPWR VPWR sky130_fd_sc_hd__decap_3
XTAP_TAPCELL_ROW_36_678 VGND VPWR sky130_fd_sc_hd__tapvpwrvgnd_1
XFILLER_21_311 VGND VGND VPWR VPWR sky130_fd_sc_hd__decap_3
XFILLER_40_119 VGND VGND VPWR VPWR sky130_fd_sc_hd__decap_3
XFILLER_80_288 VGND VGND VPWR VPWR sky130_fd_sc_hd__fill_1
XTAP_TAPCELL_ROW_36_689 VGND VPWR sky130_fd_sc_hd__tapvpwrvgnd_1
XFILLER_21_355 VGND VGND VPWR VPWR sky130_fd_sc_hd__decap_3
XFILLER_33_193 VGND VGND VPWR VPWR sky130_fd_sc_hd__decap_3
X_4816_ _3526_/B _4652_/A _4813_/A _5033_/B2 VGND VGND VPWR VPWR _4816_/X sky130_fd_sc_hd__a22o_2
XFILLER_21_399 VGND VGND VPWR VPWR sky130_fd_sc_hd__decap_3
XFILLER_31_27 VGND VGND VPWR VPWR sky130_fd_sc_hd__decap_3
XFILLER_31_49 VGND VGND VPWR VPWR sky130_fd_sc_hd__decap_3
X_4747_ _4739_/Y _4740_/X _4743_/X _4746_/X VGND VGND VPWR VPWR _5664_/B sky130_fd_sc_hd__o211a_2
XFILLER_110_9 VGND VGND VPWR VPWR sky130_fd_sc_hd__decap_3
X_4678_ _6988_/Q _4674_/X _5045_/B _5036_/A VGND VGND VPWR VPWR _5014_/B sky130_fd_sc_hd__a31o_2
X_7397_ _7397_/CLK _7397_/D _6677_/Y VGND VGND VPWR VPWR _7397_/Q sky130_fd_sc_hd__dfrtp_2
X_6417_ _6578_/A VGND VGND VPWR VPWR _6417_/Y sky130_fd_sc_hd__inv_2
X_3629_ _3629_/A VGND VGND VPWR VPWR _3629_/Y sky130_fd_sc_hd__inv_2
X_6348_ _6540_/A VGND VGND VPWR VPWR _6348_/Y sky130_fd_sc_hd__inv_2
XFILLER_102_110 VGND VGND VPWR VPWR sky130_fd_sc_hd__decap_3
XFILLER_103_644 VGND VGND VPWR VPWR sky130_fd_sc_hd__decap_3
XTAP_TAPCELL_ROW_8_348 VGND VPWR sky130_fd_sc_hd__tapvpwrvgnd_1
XFILLER_102_154 VGND VGND VPWR VPWR sky130_fd_sc_hd__decap_3
XFILLER_88_344 VGND VGND VPWR VPWR sky130_fd_sc_hd__fill_1
X_6279_ _6280_/A VGND VGND VPWR VPWR _6279_/Y sky130_fd_sc_hd__inv_2
XFILLER_29_411 VGND VGND VPWR VPWR sky130_fd_sc_hd__decap_3
XFILLER_76_539 VGND VGND VPWR VPWR sky130_fd_sc_hd__decap_3
XFILLER_29_433 VGND VGND VPWR VPWR sky130_fd_sc_hd__decap_3
XFILLER_29_455 VGND VGND VPWR VPWR sky130_fd_sc_hd__fill_1
XFILLER_56_230 VGND VGND VPWR VPWR sky130_fd_sc_hd__decap_3
XFILLER_69_591 VGND VGND VPWR VPWR sky130_fd_sc_hd__decap_3
XFILLER_17_617 VGND VGND VPWR VPWR sky130_fd_sc_hd__decap_3
XFILLER_56_274 VGND VGND VPWR VPWR sky130_fd_sc_hd__decap_3
XFILLER_56_57 VGND VGND VPWR VPWR sky130_fd_sc_hd__fill_2
XTAP_TAPCELL_ROW_55_910 VGND VPWR sky130_fd_sc_hd__tapvpwrvgnd_1
XTAP_TAPCELL_ROW_106_1518 VGND VPWR sky130_fd_sc_hd__tapvpwrvgnd_1
XFILLER_112_41 VGND VGND VPWR VPWR sky130_fd_sc_hd__decap_3
XFILLER_71_233 VGND VGND VPWR VPWR sky130_fd_sc_hd__fill_2
XTAP_TAPCELL_ROW_106_1529 VGND VPWR sky130_fd_sc_hd__tapvpwrvgnd_1
XFILLER_112_74 VGND VGND VPWR VPWR sky130_fd_sc_hd__decap_3
XFILLER_112_85 VGND VGND VPWR VPWR sky130_fd_sc_hd__decap_3
XFILLER_72_12 VGND VGND VPWR VPWR sky130_fd_sc_hd__decap_3
XFILLER_31_119 VGND VGND VPWR VPWR sky130_fd_sc_hd__decap_3
XFILLER_72_67 VGND VGND VPWR VPWR sky130_fd_sc_hd__decap_3
XFILLER_21_60 VGND VGND VPWR VPWR sky130_fd_sc_hd__decap_3
XFILLER_21_82 VGND VGND VPWR VPWR sky130_fd_sc_hd__fill_2
XFILLER_106_460 VGND VGND VPWR VPWR sky130_fd_sc_hd__decap_3
XFILLER_98_108 VGND VGND VPWR VPWR sky130_fd_sc_hd__fill_2
XFILLER_106_493 VGND VGND VPWR VPWR sky130_fd_sc_hd__decap_3
XFILLER_4_587 VGND VGND VPWR VPWR sky130_fd_sc_hd__fill_1
XFILLER_97_64 VGND VGND VPWR VPWR sky130_fd_sc_hd__fill_2
XFILLER_35_414 VGND VGND VPWR VPWR sky130_fd_sc_hd__decap_3
XFILLER_75_550 VGND VGND VPWR VPWR sky130_fd_sc_hd__fill_2
XFILLER_47_296 VGND VGND VPWR VPWR sky130_fd_sc_hd__decap_3
XFILLER_62_211 VGND VGND VPWR VPWR sky130_fd_sc_hd__decap_3
XFILLER_90_542 VGND VGND VPWR VPWR sky130_fd_sc_hd__decap_3
XFILLER_62_277 VGND VGND VPWR VPWR sky130_fd_sc_hd__decap_3
XFILLER_90_597 VGND VGND VPWR VPWR sky130_fd_sc_hd__fill_1
XFILLER_30_130 VGND VGND VPWR VPWR sky130_fd_sc_hd__decap_3
Xclkbuf_0_clk clk VGND VGND VPWR VPWR clkbuf_0_clk/X sky130_fd_sc_hd__clkbuf_16
X_5650_ _5650_/A VGND VGND VPWR VPWR _5650_/Y sky130_fd_sc_hd__inv_2
XTAP_TAPCELL_ROW_61_979 VGND VPWR sky130_fd_sc_hd__tapvpwrvgnd_1
XTAP_TAPCELL_ROW_33_648 VGND VPWR sky130_fd_sc_hd__tapvpwrvgnd_1
XFILLER_30_141 VGND VGND VPWR VPWR sky130_fd_sc_hd__decap_3
XFILLER_31_664 VGND VGND VPWR VPWR sky130_fd_sc_hd__decap_3
XFILLER_87_3 VGND VGND VPWR VPWR sky130_fd_sc_hd__decap_3
X_4601_ _7280_/Q _7248_/Q _4601_/S VGND VGND VPWR VPWR _7280_/D sky130_fd_sc_hd__mux2_2
XFILLER_30_174 VGND VGND VPWR VPWR sky130_fd_sc_hd__decap_3
X_5581_ _5581_/A0 _5069_/X _5581_/S VGND VGND VPWR VPWR _7038_/D sky130_fd_sc_hd__mux2_2
XTAP_TAPCELL_ROW_96_1400 VGND VPWR sky130_fd_sc_hd__tapvpwrvgnd_1
XFILLER_7_51 VGND VGND VPWR VPWR sky130_fd_sc_hd__decap_3
X_7320_ clkload3/A _7320_/D _6600_/Y VGND VGND VPWR VPWR _7320_/Q sky130_fd_sc_hd__dfrtp_2
X_4532_ _4532_/A0 _7281_/Q _4534_/S VGND VGND VPWR VPWR _7313_/D sky130_fd_sc_hd__mux2_2
XFILLER_7_370 VGND VGND VPWR VPWR sky130_fd_sc_hd__decap_3
XFILLER_7_84 VGND VGND VPWR VPWR sky130_fd_sc_hd__decap_3
X_7251_ clkload5/A _7251_/D _6531_/Y VGND VGND VPWR VPWR _7251_/Q sky130_fd_sc_hd__dfrtp_2
X_4463_ _4460_/Y _3541_/B _5057_/A _4462_/Y VGND VGND VPWR VPWR _4463_/X sky130_fd_sc_hd__a22o_2
XFILLER_116_268 VGND VGND VPWR VPWR sky130_fd_sc_hd__decap_3
XFILLER_89_108 VGND VGND VPWR VPWR sky130_fd_sc_hd__decap_3
X_3414_ _3421_/C VGND VGND VPWR VPWR _3449_/C sky130_fd_sc_hd__inv_4
X_7182_ _7310_/CLK _7182_/D _6462_/Y VGND VGND VPWR VPWR _7182_/Q sky130_fd_sc_hd__dfrtp_2
X_4394_ _4394_/A _4394_/B _4393_/X VGND VGND VPWR VPWR _4444_/B sky130_fd_sc_hd__or3b_2
XPHY_EDGE_ROW_15_Right_15 VGND VGND VPWR VPWR sky130_fd_sc_hd__decap_3
XFILLER_98_642 VGND VGND VPWR VPWR sky130_fd_sc_hd__fill_2
XFILLER_58_506 VGND VGND VPWR VPWR sky130_fd_sc_hd__decap_3
X_3345_ _5642_/A _4677_/B VGND VGND VPWR VPWR _3346_/A sky130_fd_sc_hd__nor2_4
XTAP_TAPCELL_ROW_5_307 VGND VPWR sky130_fd_sc_hd__tapvpwrvgnd_1
XFILLER_98_675 VGND VGND VPWR VPWR sky130_fd_sc_hd__decap_3
XFILLER_112_474 VGND VGND VPWR VPWR sky130_fd_sc_hd__fill_2
XFILLER_85_314 VGND VGND VPWR VPWR sky130_fd_sc_hd__decap_3
XFILLER_97_163 VGND VGND VPWR VPWR sky130_fd_sc_hd__decap_3
Xhold1004 _7201_/Q VGND VGND VPWR VPWR _5258_/A0 sky130_fd_sc_hd__dlygate4sd3_1
Xhold1015 _7266_/Q VGND VGND VPWR VPWR _4933_/A0 sky130_fd_sc_hd__dlygate4sd3_1
XFILLER_100_669 VGND VGND VPWR VPWR sky130_fd_sc_hd__decap_3
XFILLER_97_196 VGND VGND VPWR VPWR sky130_fd_sc_hd__decap_3
Xhold1026 _7204_/Q VGND VGND VPWR VPWR _5251_/A0 sky130_fd_sc_hd__dlygate4sd3_1
Xhold1037 _7040_/Q VGND VGND VPWR VPWR _5577_/A0 sky130_fd_sc_hd__dlygate4sd3_1
Xhold1048 _7243_/Q VGND VGND VPWR VPWR _5169_/A sky130_fd_sc_hd__dlygate4sd3_1
X_5015_ _5015_/A _5015_/B _5015_/C VGND VGND VPWR VPWR _5015_/X sky130_fd_sc_hd__and3_2
XFILLER_66_550 VGND VGND VPWR VPWR sky130_fd_sc_hd__decap_3
Xhold1059 _7257_/Q VGND VGND VPWR VPWR _5080_/A0 sky130_fd_sc_hd__dlygate4sd3_1
XFILLER_26_27 VGND VGND VPWR VPWR sky130_fd_sc_hd__fill_1
XFILLER_38_296 VGND VGND VPWR VPWR sky130_fd_sc_hd__decap_3
XFILLER_41_406 VGND VGND VPWR VPWR sky130_fd_sc_hd__decap_3
XFILLER_53_255 VGND VGND VPWR VPWR sky130_fd_sc_hd__decap_3
X_6966_ _6976_/CLK _6966_/D VGND VGND VPWR VPWR _6966_/Q sky130_fd_sc_hd__dfxtp_2
XPHY_EDGE_ROW_24_Right_24 VGND VGND VPWR VPWR sky130_fd_sc_hd__decap_3
XFILLER_42_15 VGND VGND VPWR VPWR sky130_fd_sc_hd__decap_3
X_6897_ _6965_/CLK _6897_/D VGND VGND VPWR VPWR _6897_/Q sky130_fd_sc_hd__dfxtp_2
XFILLER_22_664 VGND VGND VPWR VPWR sky130_fd_sc_hd__fill_1
XFILLER_42_37 VGND VGND VPWR VPWR sky130_fd_sc_hd__decap_3
XTAP_TAPCELL_ROW_101_1459 VGND VPWR sky130_fd_sc_hd__tapvpwrvgnd_1
XPHY_EDGE_ROW_33_Right_33 VGND VGND VPWR VPWR sky130_fd_sc_hd__decap_3
XFILLER_107_41 VGND VGND VPWR VPWR sky130_fd_sc_hd__decap_3
XFILLER_89_620 VGND VGND VPWR VPWR sky130_fd_sc_hd__decap_3
Xhold860 _7085_/Q VGND VGND VPWR VPWR _7085_/D sky130_fd_sc_hd__dlygate4sd3_1
Xhold871 _7096_/Q VGND VGND VPWR VPWR _7096_/D sky130_fd_sc_hd__dlygate4sd3_1
Xhold882 _7060_/Q VGND VGND VPWR VPWR _7060_/D sky130_fd_sc_hd__dlygate4sd3_1
XFILLER_103_441 VGND VGND VPWR VPWR sky130_fd_sc_hd__decap_3
XFILLER_103_452 VGND VGND VPWR VPWR sky130_fd_sc_hd__decap_3
XFILLER_107_63 VGND VGND VPWR VPWR sky130_fd_sc_hd__decap_3
XFILLER_115_290 VGND VGND VPWR VPWR sky130_fd_sc_hd__decap_3
XFILLER_67_12 VGND VGND VPWR VPWR sky130_fd_sc_hd__decap_3
XFILLER_89_653 VGND VGND VPWR VPWR sky130_fd_sc_hd__decap_3
Xhold893 _7086_/Q VGND VGND VPWR VPWR _7086_/D sky130_fd_sc_hd__dlygate4sd3_1
XFILLER_107_96 VGND VGND VPWR VPWR sky130_fd_sc_hd__decap_3
XFILLER_67_45 VGND VGND VPWR VPWR sky130_fd_sc_hd__decap_3
XFILLER_88_152 VGND VGND VPWR VPWR sky130_fd_sc_hd__decap_3
XTAP_TAPCELL_ROW_112_1599 VGND VPWR sky130_fd_sc_hd__tapvpwrvgnd_1
XFILLER_76_336 VGND VGND VPWR VPWR sky130_fd_sc_hd__decap_3
XFILLER_76_358 VGND VGND VPWR VPWR sky130_fd_sc_hd__decap_3
XFILLER_57_561 VGND VGND VPWR VPWR sky130_fd_sc_hd__decap_3
XFILLER_57_594 VGND VGND VPWR VPWR sky130_fd_sc_hd__decap_3
XFILLER_72_520 VGND VGND VPWR VPWR sky130_fd_sc_hd__decap_3
XPHY_EDGE_ROW_42_Right_42 VGND VGND VPWR VPWR sky130_fd_sc_hd__decap_3
XFILLER_83_66 VGND VGND VPWR VPWR sky130_fd_sc_hd__fill_1
XTAP_TAPCELL_ROW_67_1056 VGND VPWR sky130_fd_sc_hd__tapvpwrvgnd_1
XFILLER_16_71 VGND VGND VPWR VPWR sky130_fd_sc_hd__decap_3
XFILLER_13_653 VGND VGND VPWR VPWR sky130_fd_sc_hd__decap_3
XTAP_TAPCELL_ROW_80_1212 VGND VPWR sky130_fd_sc_hd__tapvpwrvgnd_1
XFILLER_12_141 VGND VGND VPWR VPWR sky130_fd_sc_hd__decap_3
XFILLER_8_112 VGND VGND VPWR VPWR sky130_fd_sc_hd__decap_3
XTAP_TAPCELL_ROW_30_607 VGND VPWR sky130_fd_sc_hd__tapvpwrvgnd_1
XFILLER_73_9 VGND VGND VPWR VPWR sky130_fd_sc_hd__decap_3
XFILLER_9_657 VGND VGND VPWR VPWR sky130_fd_sc_hd__decap_3
XFILLER_32_81 VGND VGND VPWR VPWR sky130_fd_sc_hd__decap_3
XFILLER_8_178 VGND VGND VPWR VPWR sky130_fd_sc_hd__decap_3
XPHY_EDGE_ROW_51_Right_51 VGND VGND VPWR VPWR sky130_fd_sc_hd__decap_3
XFILLER_9_679 VGND VGND VPWR VPWR sky130_fd_sc_hd__decap_3
XTAP_TAPCELL_ROW_10_375 VGND VPWR sky130_fd_sc_hd__tapvpwrvgnd_1
XFILLER_113_205 VGND VGND VPWR VPWR sky130_fd_sc_hd__decap_3
XTAP_TAPCELL_ROW_78_1185 VGND VPWR sky130_fd_sc_hd__tapvpwrvgnd_1
XFILLER_113_249 VGND VGND VPWR VPWR sky130_fd_sc_hd__decap_3
XTAP_TAPCELL_ROW_91_1341 VGND VPWR sky130_fd_sc_hd__tapvpwrvgnd_1
XFILLER_94_100 VGND VGND VPWR VPWR sky130_fd_sc_hd__decap_3
XFILLER_95_623 VGND VGND VPWR VPWR sky130_fd_sc_hd__decap_3
XFILLER_94_144 VGND VGND VPWR VPWR sky130_fd_sc_hd__decap_3
XFILLER_95_656 VGND VGND VPWR VPWR sky130_fd_sc_hd__decap_3
XFILLER_48_550 VGND VGND VPWR VPWR sky130_fd_sc_hd__fill_2
XFILLER_82_306 VGND VGND VPWR VPWR sky130_fd_sc_hd__fill_2
XTAP_TAPCELL_ROW_38_707 VGND VPWR sky130_fd_sc_hd__tapvpwrvgnd_1
XPHY_EDGE_ROW_60_Right_60 VGND VGND VPWR VPWR sky130_fd_sc_hd__decap_3
XFILLER_35_211 VGND VGND VPWR VPWR sky130_fd_sc_hd__decap_3
XFILLER_48_583 VGND VGND VPWR VPWR sky130_fd_sc_hd__decap_3
XFILLER_75_380 VGND VGND VPWR VPWR sky130_fd_sc_hd__decap_3
XFILLER_94_188 VGND VGND VPWR VPWR sky130_fd_sc_hd__decap_3
X_6820_ _6975_/CLK _6820_/D VGND VGND VPWR VPWR _6820_/Q sky130_fd_sc_hd__dfxtp_2
XFILLER_35_277 VGND VGND VPWR VPWR sky130_fd_sc_hd__decap_3
XFILLER_50_203 VGND VGND VPWR VPWR sky130_fd_sc_hd__decap_3
XFILLER_63_586 VGND VGND VPWR VPWR sky130_fd_sc_hd__decap_3
XFILLER_90_361 VGND VGND VPWR VPWR sky130_fd_sc_hd__decap_3
XTAP_TAPCELL_ROW_18_464 VGND VPWR sky130_fd_sc_hd__tapvpwrvgnd_1
X_6751_ _6970_/CLK _6751_/D VGND VGND VPWR VPWR _6751_/Q sky130_fd_sc_hd__dfxtp_2
XFILLER_31_461 VGND VGND VPWR VPWR sky130_fd_sc_hd__decap_3
X_6682_ _6682_/A VGND VGND VPWR VPWR _6682_/Y sky130_fd_sc_hd__inv_2
X_3894_ _3728_/Y _3891_/X _3893_/X _3733_/X VGND VGND VPWR VPWR _3894_/X sky130_fd_sc_hd__a22o_2
XFILLER_12_18 VGND VGND VPWR VPWR sky130_fd_sc_hd__decap_3
X_5633_ _5633_/A _5633_/B VGND VGND VPWR VPWR _7012_/D sky130_fd_sc_hd__nor2_2
XFILLER_12_29 VGND VGND VPWR VPWR sky130_fd_sc_hd__decap_3
X_5564_ hold980/X _4909_/A _4751_/B VGND VGND VPWR VPWR _7052_/D sky130_fd_sc_hd__a21bo_2
X_7303_ _7337_/CLK _7303_/D _6583_/Y VGND VGND VPWR VPWR _7303_/Q sky130_fd_sc_hd__dfrtp_2
X_4515_ _4515_/A0 _7290_/Q _4534_/S VGND VGND VPWR VPWR _7322_/D sky130_fd_sc_hd__mux2_2
XPHY_EDGE_ROW_103_Right_103 VGND VGND VPWR VPWR sky130_fd_sc_hd__decap_3
XFILLER_104_238 VGND VGND VPWR VPWR sky130_fd_sc_hd__decap_3
X_7234_ _7234_/CLK _7234_/D _6514_/Y VGND VGND VPWR VPWR _7234_/Q sky130_fd_sc_hd__dfrtp_2
X_4446_ _4446_/A _4814_/B VGND VGND VPWR VPWR _4447_/B sky130_fd_sc_hd__nor2_2
X_7165_ _7294_/CLK _7165_/D _6445_/Y VGND VGND VPWR VPWR _7165_/Q sky130_fd_sc_hd__dfrtp_2
X_4377_ _4620_/C _4375_/X _4376_/X VGND VGND VPWR VPWR _4377_/Y sky130_fd_sc_hd__o21ai_2
XFILLER_98_450 VGND VGND VPWR VPWR sky130_fd_sc_hd__decap_3
XFILLER_85_100 VGND VGND VPWR VPWR sky130_fd_sc_hd__decap_3
XFILLER_86_612 VGND VGND VPWR VPWR sky130_fd_sc_hd__decap_3
X_3328_ _3328_/A _3328_/B VGND VGND VPWR VPWR _3340_/C sky130_fd_sc_hd__nor2_2
XPHY_EDGE_ROW_13_Left_130 VGND VGND VPWR VPWR sky130_fd_sc_hd__decap_3
XFILLER_37_15 VGND VGND VPWR VPWR sky130_fd_sc_hd__decap_3
XFILLER_58_336 VGND VGND VPWR VPWR sky130_fd_sc_hd__decap_3
XFILLER_85_122 VGND VGND VPWR VPWR sky130_fd_sc_hd__fill_2
XFILLER_86_645 VGND VGND VPWR VPWR sky130_fd_sc_hd__decap_3
X_7096_ clkload5/A _7096_/D _6376_/Y VGND VGND VPWR VPWR _7096_/Q sky130_fd_sc_hd__dfrtp_2
XFILLER_100_466 VGND VGND VPWR VPWR sky130_fd_sc_hd__decap_3
XFILLER_37_48 VGND VGND VPWR VPWR sky130_fd_sc_hd__decap_3
XFILLER_39_561 VGND VGND VPWR VPWR sky130_fd_sc_hd__decap_3
XFILLER_85_166 VGND VGND VPWR VPWR sky130_fd_sc_hd__fill_2
XFILLER_86_678 VGND VGND VPWR VPWR sky130_fd_sc_hd__decap_3
XFILLER_26_200 VGND VGND VPWR VPWR sky130_fd_sc_hd__decap_3
XFILLER_85_199 VGND VGND VPWR VPWR sky130_fd_sc_hd__decap_3
XFILLER_81_350 VGND VGND VPWR VPWR sky130_fd_sc_hd__decap_3
XFILLER_26_277 VGND VGND VPWR VPWR sky130_fd_sc_hd__decap_3
XFILLER_53_36 VGND VGND VPWR VPWR sky130_fd_sc_hd__decap_3
XFILLER_54_586 VGND VGND VPWR VPWR sky130_fd_sc_hd__fill_2
XFILLER_26_299 VGND VGND VPWR VPWR sky130_fd_sc_hd__decap_3
XFILLER_41_225 VGND VGND VPWR VPWR sky130_fd_sc_hd__decap_3
X_6949_ _6972_/CLK _6949_/D VGND VGND VPWR VPWR _6949_/Q sky130_fd_sc_hd__dfxtp_2
XFILLER_22_472 VGND VGND VPWR VPWR sky130_fd_sc_hd__decap_3
XFILLER_22_483 VGND VGND VPWR VPWR sky130_fd_sc_hd__fill_2
XFILLER_10_656 VGND VGND VPWR VPWR sky130_fd_sc_hd__decap_3
XFILLER_10_689 VGND VGND VPWR VPWR sky130_fd_sc_hd__decap_3
XFILLER_5_137 VGND VGND VPWR VPWR sky130_fd_sc_hd__decap_3
XFILLER_6_638 VGND VGND VPWR VPWR sky130_fd_sc_hd__decap_3
XTAP_TAPCELL_ROW_114_1617 VGND VPWR sky130_fd_sc_hd__tapvpwrvgnd_1
XFILLER_78_22 VGND VGND VPWR VPWR sky130_fd_sc_hd__decap_3
Xhold690 _6920_/Q VGND VGND VPWR VPWR _6920_/D sky130_fd_sc_hd__dlygate4sd3_1
XFILLER_1_376 VGND VGND VPWR VPWR sky130_fd_sc_hd__decap_3
XFILLER_103_293 VGND VGND VPWR VPWR sky130_fd_sc_hd__decap_3
XFILLER_49_325 VGND VGND VPWR VPWR sky130_fd_sc_hd__decap_3
XFILLER_77_645 VGND VGND VPWR VPWR sky130_fd_sc_hd__decap_3
XFILLER_64_306 VGND VGND VPWR VPWR sky130_fd_sc_hd__fill_2
XFILLER_76_144 VGND VGND VPWR VPWR sky130_fd_sc_hd__decap_3
XFILLER_92_626 VGND VGND VPWR VPWR sky130_fd_sc_hd__decap_3
XFILLER_94_21 VGND VGND VPWR VPWR sky130_fd_sc_hd__fill_1
XFILLER_94_43 VGND VGND VPWR VPWR sky130_fd_sc_hd__decap_3
XFILLER_91_125 VGND VGND VPWR VPWR sky130_fd_sc_hd__decap_3
XFILLER_92_648 VGND VGND VPWR VPWR sky130_fd_sc_hd__decap_3
XFILLER_17_222 VGND VGND VPWR VPWR sky130_fd_sc_hd__fill_2
XFILLER_17_255 VGND VGND VPWR VPWR sky130_fd_sc_hd__decap_3
XFILLER_27_81 VGND VGND VPWR VPWR sky130_fd_sc_hd__decap_3
XFILLER_45_542 VGND VGND VPWR VPWR sky130_fd_sc_hd__fill_1
XFILLER_45_564 VGND VGND VPWR VPWR sky130_fd_sc_hd__decap_3
XFILLER_91_169 VGND VGND VPWR VPWR sky130_fd_sc_hd__decap_3
XFILLER_17_266 VGND VGND VPWR VPWR sky130_fd_sc_hd__decap_3
XFILLER_32_203 VGND VGND VPWR VPWR sky130_fd_sc_hd__decap_3
XFILLER_32_225 VGND VGND VPWR VPWR sky130_fd_sc_hd__decap_3
XTAP_TAPCELL_ROW_15_434 VGND VPWR sky130_fd_sc_hd__tapvpwrvgnd_1
XFILLER_13_461 VGND VGND VPWR VPWR sky130_fd_sc_hd__decap_3
XFILLER_60_567 VGND VGND VPWR VPWR sky130_fd_sc_hd__decap_3
XFILLER_60_589 VGND VGND VPWR VPWR sky130_fd_sc_hd__decap_3
XTAP_TAPCELL_ROW_43_765 VGND VPWR sky130_fd_sc_hd__tapvpwrvgnd_1
XFILLER_71_6 VGND VGND VPWR VPWR sky130_fd_sc_hd__decap_3
XFILLER_9_487 VGND VGND VPWR VPWR sky130_fd_sc_hd__fill_2
XFILLER_114_503 VGND VGND VPWR VPWR sky130_fd_sc_hd__decap_3
XFILLER_114_536 VGND VGND VPWR VPWR sky130_fd_sc_hd__decap_3
XFILLER_5_671 VGND VGND VPWR VPWR sky130_fd_sc_hd__fill_1
XFILLER_5_682 VGND VGND VPWR VPWR sky130_fd_sc_hd__decap_3
X_5280_ _5280_/A0 _5121_/X _5292_/S VGND VGND VPWR VPWR _7190_/D sky130_fd_sc_hd__mux2_2
X_4300_ _7288_/Q _4522_/S VGND VGND VPWR VPWR _4300_/X sky130_fd_sc_hd__and2_2
XFILLER_99_236 VGND VGND VPWR VPWR sky130_fd_sc_hd__decap_3
XFILLER_114_569 VGND VGND VPWR VPWR sky130_fd_sc_hd__decap_3
XFILLER_4_41 VGND VGND VPWR VPWR sky130_fd_sc_hd__decap_3
X_4231_ _7040_/Q _4517_/S _4261_/A2 _7387_/Q _4230_/X VGND VGND VPWR VPWR _4231_/X
+ sky130_fd_sc_hd__a221o_2
XFILLER_99_269 VGND VGND VPWR VPWR sky130_fd_sc_hd__decap_3
XFILLER_4_74 VGND VGND VPWR VPWR sky130_fd_sc_hd__decap_3
XFILLER_4_85 VGND VGND VPWR VPWR sky130_fd_sc_hd__decap_3
XFILLER_68_623 VGND VGND VPWR VPWR sky130_fd_sc_hd__decap_3
XFILLER_67_111 VGND VGND VPWR VPWR sky130_fd_sc_hd__fill_1
XFILLER_68_645 VGND VGND VPWR VPWR sky130_fd_sc_hd__decap_3
XFILLER_95_420 VGND VGND VPWR VPWR sky130_fd_sc_hd__fill_2
X_4162_ _7137_/Q _4420_/B1 _4161_/X VGND VGND VPWR VPWR _4203_/A sky130_fd_sc_hd__a21o_2
XFILLER_68_678 VGND VGND VPWR VPWR sky130_fd_sc_hd__decap_3
XFILLER_83_604 VGND VGND VPWR VPWR sky130_fd_sc_hd__decap_3
X_4093_ _4394_/A _4394_/B _4092_/X VGND VGND VPWR VPWR _4210_/B sky130_fd_sc_hd__or3b_2
XFILLER_48_380 VGND VGND VPWR VPWR sky130_fd_sc_hd__decap_3
XFILLER_82_114 VGND VGND VPWR VPWR sky130_fd_sc_hd__decap_3
XFILLER_82_125 VGND VGND VPWR VPWR sky130_fd_sc_hd__decap_3
XFILLER_83_626 VGND VGND VPWR VPWR sky130_fd_sc_hd__decap_3
XFILLER_83_659 VGND VGND VPWR VPWR sky130_fd_sc_hd__decap_3
XFILLER_95_497 VGND VGND VPWR VPWR sky130_fd_sc_hd__decap_3
XFILLER_36_553 VGND VGND VPWR VPWR sky130_fd_sc_hd__fill_2
XFILLER_70_309 VGND VGND VPWR VPWR sky130_fd_sc_hd__decap_3
XFILLER_82_136 VGND VGND VPWR VPWR sky130_fd_sc_hd__decap_3
XFILLER_23_214 VGND VGND VPWR VPWR sky130_fd_sc_hd__fill_1
XFILLER_36_575 VGND VGND VPWR VPWR sky130_fd_sc_hd__decap_3
XFILLER_36_597 VGND VGND VPWR VPWR sky130_fd_sc_hd__fill_2
XFILLER_63_361 VGND VGND VPWR VPWR sky130_fd_sc_hd__decap_3
XFILLER_23_225 VGND VGND VPWR VPWR sky130_fd_sc_hd__decap_3
XFILLER_51_556 VGND VGND VPWR VPWR sky130_fd_sc_hd__decap_3
XFILLER_90_180 VGND VGND VPWR VPWR sky130_fd_sc_hd__fill_1
Xplace372 _3864_/S VGND VGND VPWR VPWR _5151_/A sky130_fd_sc_hd__buf_2
Xplace361 _3409_/X VGND VGND VPWR VPWR _4352_/B1 sky130_fd_sc_hd__buf_2
Xplace350 _4351_/A2 VGND VGND VPWR VPWR _4250_/A2 sky130_fd_sc_hd__buf_2
X_6803_ _7005_/CLK _6803_/D VGND VGND VPWR VPWR _6803_/Q sky130_fd_sc_hd__dfxtp_2
X_4995_ _4811_/C _4987_/Y _4993_/X _4994_/X VGND VGND VPWR VPWR _5657_/D sky130_fd_sc_hd__a211o_2
XFILLER_23_258 VGND VGND VPWR VPWR sky130_fd_sc_hd__decap_3
Xplace383 _3334_/Y VGND VGND VPWR VPWR _3339_/C1 sky130_fd_sc_hd__buf_2
Xplace394 _5360_/S VGND VGND VPWR VPWR _5358_/S sky130_fd_sc_hd__buf_2
X_6734_ _6976_/CLK _6734_/D VGND VGND VPWR VPWR _6734_/Q sky130_fd_sc_hd__dfxtp_2
XFILLER_23_39 VGND VGND VPWR VPWR sky130_fd_sc_hd__decap_3
X_6665_ _6670_/A VGND VGND VPWR VPWR _6665_/Y sky130_fd_sc_hd__inv_2
X_3877_ _6906_/Q _3879_/A2 _3884_/B1 _6850_/Q _3876_/X VGND VGND VPWR VPWR _3877_/X
+ sky130_fd_sc_hd__a221o_2
X_6596_ _6599_/A VGND VGND VPWR VPWR _6596_/Y sky130_fd_sc_hd__inv_2
XFILLER_3_608 VGND VGND VPWR VPWR sky130_fd_sc_hd__decap_3
XFILLER_105_525 VGND VGND VPWR VPWR sky130_fd_sc_hd__decap_3
XFILLER_2_118 VGND VGND VPWR VPWR sky130_fd_sc_hd__decap_3
XFILLER_3_9 VGND VGND VPWR VPWR sky130_fd_sc_hd__decap_3
X_7217_ clkload9/A _7217_/D _6497_/Y VGND VGND VPWR VPWR _7217_/Q sky130_fd_sc_hd__dfrtp_2
X_4429_ _7303_/Q _4482_/S _4429_/B1 _7367_/Q _4429_/C1 VGND VGND VPWR VPWR _4429_/X
+ sky130_fd_sc_hd__a221o_2
XFILLER_59_623 VGND VGND VPWR VPWR sky130_fd_sc_hd__decap_3
XFILLER_113_591 VGND VGND VPWR VPWR sky130_fd_sc_hd__decap_3
XFILLER_58_100 VGND VGND VPWR VPWR sky130_fd_sc_hd__decap_3
XFILLER_59_656 VGND VGND VPWR VPWR sky130_fd_sc_hd__decap_3
X_7148_ _7310_/CLK _7148_/D _6428_/Y VGND VGND VPWR VPWR _7148_/Q sky130_fd_sc_hd__dfrtp_2
XFILLER_100_241 VGND VGND VPWR VPWR sky130_fd_sc_hd__decap_3
XFILLER_46_306 VGND VGND VPWR VPWR sky130_fd_sc_hd__fill_2
XFILLER_48_69 VGND VGND VPWR VPWR sky130_fd_sc_hd__decap_3
XFILLER_58_144 VGND VGND VPWR VPWR sky130_fd_sc_hd__decap_3
XFILLER_74_604 VGND VGND VPWR VPWR sky130_fd_sc_hd__decap_3
X_7079_ _7234_/CLK _7079_/D _6359_/Y VGND VGND VPWR VPWR _7079_/Q sky130_fd_sc_hd__dfrtp_2
XFILLER_100_285 VGND VGND VPWR VPWR sky130_fd_sc_hd__decap_3
XFILLER_58_188 VGND VGND VPWR VPWR sky130_fd_sc_hd__decap_3
XFILLER_74_648 VGND VGND VPWR VPWR sky130_fd_sc_hd__decap_3
XFILLER_104_97 VGND VGND VPWR VPWR sky130_fd_sc_hd__decap_3
XFILLER_27_531 VGND VGND VPWR VPWR sky130_fd_sc_hd__decap_3
XFILLER_27_553 VGND VGND VPWR VPWR sky130_fd_sc_hd__decap_3
XFILLER_64_24 VGND VGND VPWR VPWR sky130_fd_sc_hd__decap_3
XFILLER_73_136 VGND VGND VPWR VPWR sky130_fd_sc_hd__decap_3
XFILLER_14_203 VGND VGND VPWR VPWR sky130_fd_sc_hd__fill_1
XFILLER_27_564 VGND VGND VPWR VPWR sky130_fd_sc_hd__fill_1
XFILLER_64_46 VGND VGND VPWR VPWR sky130_fd_sc_hd__decap_3
XFILLER_82_681 VGND VGND VPWR VPWR sky130_fd_sc_hd__decap_3
XTAP_TAPCELL_ROW_64_1015 VGND VPWR sky130_fd_sc_hd__tapvpwrvgnd_1
XFILLER_14_236 VGND VGND VPWR VPWR sky130_fd_sc_hd__decap_3
XFILLER_27_597 VGND VGND VPWR VPWR sky130_fd_sc_hd__decap_3
XFILLER_54_383 VGND VGND VPWR VPWR sky130_fd_sc_hd__decap_3
XFILLER_80_12 VGND VGND VPWR VPWR sky130_fd_sc_hd__decap_3
Xfanout40 _6547_/A VGND VGND VPWR VPWR _6548_/A sky130_fd_sc_hd__buf_2
Xfanout51 reset VGND VGND VPWR VPWR fanout51/X sky130_fd_sc_hd__clkdlybuf4s25_1
Xfanout62 fanout72/X VGND VGND VPWR VPWR _6587_/A sky130_fd_sc_hd__clkdlybuf4s25_1
Xfanout73 reset VGND VGND VPWR VPWR _6652_/A sky130_fd_sc_hd__buf_1
XTAP_TAPCELL_ROW_40_735 VGND VPWR sky130_fd_sc_hd__tapvpwrvgnd_1
XFILLER_13_50 VGND VGND VPWR VPWR sky130_fd_sc_hd__decap_3
XFILLER_22_291 VGND VGND VPWR VPWR sky130_fd_sc_hd__decap_3
XFILLER_6_402 VGND VGND VPWR VPWR sky130_fd_sc_hd__decap_3
XFILLER_13_72 VGND VGND VPWR VPWR sky130_fd_sc_hd__decap_3
XFILLER_6_424 VGND VGND VPWR VPWR sky130_fd_sc_hd__decap_3
XFILLER_10_497 VGND VGND VPWR VPWR sky130_fd_sc_hd__decap_3
XFILLER_6_457 VGND VGND VPWR VPWR sky130_fd_sc_hd__decap_3
XFILLER_89_21 VGND VGND VPWR VPWR sky130_fd_sc_hd__decap_3
XTAP_TAPCELL_ROW_20_492 VGND VPWR sky130_fd_sc_hd__tapvpwrvgnd_1
XFILLER_108_363 VGND VGND VPWR VPWR sky130_fd_sc_hd__fill_1
XFILLER_2_630 VGND VGND VPWR VPWR sky130_fd_sc_hd__decap_3
XTAP_TAPCELL_ROW_75_1155 VGND VPWR sky130_fd_sc_hd__tapvpwrvgnd_1
XFILLER_1_140 VGND VGND VPWR VPWR sky130_fd_sc_hd__decap_3
XFILLER_2_663 VGND VGND VPWR VPWR sky130_fd_sc_hd__decap_3
XFILLER_36_9 VGND VGND VPWR VPWR sky130_fd_sc_hd__decap_3
XFILLER_96_228 VGND VGND VPWR VPWR sky130_fd_sc_hd__decap_3
XFILLER_49_122 VGND VGND VPWR VPWR sky130_fd_sc_hd__fill_1
XFILLER_49_144 VGND VGND VPWR VPWR sky130_fd_sc_hd__decap_3
XFILLER_65_615 VGND VGND VPWR VPWR sky130_fd_sc_hd__fill_1
XFILLER_77_464 VGND VGND VPWR VPWR sky130_fd_sc_hd__fill_1
XFILLER_65_626 VGND VGND VPWR VPWR sky130_fd_sc_hd__decap_3
XFILLER_77_486 VGND VGND VPWR VPWR sky130_fd_sc_hd__decap_3
XFILLER_92_401 VGND VGND VPWR VPWR sky130_fd_sc_hd__decap_3
XTAP_TAPCELL_ROW_48_824 VGND VPWR sky130_fd_sc_hd__tapvpwrvgnd_1
XFILLER_18_542 VGND VGND VPWR VPWR sky130_fd_sc_hd__decap_3
XFILLER_64_136 VGND VGND VPWR VPWR sky130_fd_sc_hd__decap_3
XFILLER_64_147 VGND VGND VPWR VPWR sky130_fd_sc_hd__decap_3
XFILLER_65_659 VGND VGND VPWR VPWR sky130_fd_sc_hd__decap_3
XFILLER_92_445 VGND VGND VPWR VPWR sky130_fd_sc_hd__decap_3
XFILLER_33_512 VGND VGND VPWR VPWR sky130_fd_sc_hd__decap_3
XFILLER_45_372 VGND VGND VPWR VPWR sky130_fd_sc_hd__decap_3
XFILLER_52_309 VGND VGND VPWR VPWR sky130_fd_sc_hd__decap_3
XFILLER_80_618 VGND VGND VPWR VPWR sky130_fd_sc_hd__decap_3
XFILLER_45_383 VGND VGND VPWR VPWR sky130_fd_sc_hd__fill_1
XFILLER_72_180 VGND VGND VPWR VPWR sky130_fd_sc_hd__decap_3
XTAP_TAPCELL_ROW_86_1284 VGND VPWR sky130_fd_sc_hd__tapvpwrvgnd_1
XTAP_TAPCELL_ROW_28_592 VGND VPWR sky130_fd_sc_hd__tapvpwrvgnd_1
X_4780_ _4779_/X _4447_/B _4795_/A VGND VGND VPWR VPWR _4780_/Y sky130_fd_sc_hd__a21oi_2
X_3800_ _6861_/Q _3651_/Y _3892_/B1 _6901_/Q _3799_/X VGND VGND VPWR VPWR _3800_/X
+ sky130_fd_sc_hd__a221o_2
XFILLER_20_217 VGND VGND VPWR VPWR sky130_fd_sc_hd__decap_3
X_3731_ _6758_/Q _3913_/B1 _3912_/B1 _6770_/Q VGND VGND VPWR VPWR _3731_/X sky130_fd_sc_hd__a22o_2
Xclkload10 _7312_/CLK VGND VGND VPWR VPWR clkload10/X sky130_fd_sc_hd__clkbuf_8
X_6450_ _6611_/A VGND VGND VPWR VPWR _6450_/Y sky130_fd_sc_hd__inv_2
Xclkload21 _7364_/CLK VGND VGND VPWR VPWR clkload21/X sky130_fd_sc_hd__clkbuf_1
Xclkload32 _7387_/CLK VGND VGND VPWR VPWR clkload32/Y sky130_fd_sc_hd__clkinv_2
X_6381_ _6539_/A VGND VGND VPWR VPWR _6381_/Y sky130_fd_sc_hd__inv_2
X_3593_ _3620_/A _4292_/B _3592_/X VGND VGND VPWR VPWR _3594_/B sky130_fd_sc_hd__a21o_2
XFILLER_114_333 VGND VGND VPWR VPWR sky130_fd_sc_hd__decap_3
XFILLER_102_539 VGND VGND VPWR VPWR sky130_fd_sc_hd__fill_2
XFILLER_87_228 VGND VGND VPWR VPWR sky130_fd_sc_hd__decap_3
X_7002_ _7406_/CLK _7002_/D _6282_/Y VGND VGND VPWR VPWR _7002_/Q sky130_fd_sc_hd__dfrtp_2
X_5194_ _5194_/A _5205_/B VGND VGND VPWR VPWR _7231_/D sky130_fd_sc_hd__and2_2
X_4214_ _7228_/Q _4262_/A2 _3366_/X _7164_/Q _4213_/X VGND VGND VPWR VPWR _4214_/X
+ sky130_fd_sc_hd__a221o_2
XFILLER_56_604 VGND VGND VPWR VPWR sky130_fd_sc_hd__decap_3
XFILLER_68_453 VGND VGND VPWR VPWR sky130_fd_sc_hd__decap_3
X_4145_ _7298_/Q _4501_/S _4144_/X _4248_/A VGND VGND VPWR VPWR _4145_/X sky130_fd_sc_hd__a211o_2
XFILLER_110_572 VGND VGND VPWR VPWR sky130_fd_sc_hd__decap_3
XFILLER_56_637 VGND VGND VPWR VPWR sky130_fd_sc_hd__decap_3
XFILLER_56_648 VGND VGND VPWR VPWR sky130_fd_sc_hd__decap_3
XFILLER_68_475 VGND VGND VPWR VPWR sky130_fd_sc_hd__fill_1
XFILLER_95_261 VGND VGND VPWR VPWR sky130_fd_sc_hd__decap_3
XFILLER_55_136 VGND VGND VPWR VPWR sky130_fd_sc_hd__decap_3
XFILLER_71_607 VGND VGND VPWR VPWR sky130_fd_sc_hd__decap_3
XFILLER_83_445 VGND VGND VPWR VPWR sky130_fd_sc_hd__decap_3
XFILLER_95_294 VGND VGND VPWR VPWR sky130_fd_sc_hd__decap_3
X_4076_ _7147_/Q _4434_/B1 _4436_/B1 _7179_/Q VGND VGND VPWR VPWR _4076_/X sky130_fd_sc_hd__a22o_2
XFILLER_24_512 VGND VGND VPWR VPWR sky130_fd_sc_hd__decap_3
XFILLER_55_169 VGND VGND VPWR VPWR sky130_fd_sc_hd__decap_3
XFILLER_64_681 VGND VGND VPWR VPWR sky130_fd_sc_hd__decap_3
XFILLER_71_629 VGND VGND VPWR VPWR sky130_fd_sc_hd__decap_3
XFILLER_34_27 VGND VGND VPWR VPWR sky130_fd_sc_hd__fill_1
XFILLER_51_331 VGND VGND VPWR VPWR sky130_fd_sc_hd__decap_3
XFILLER_63_180 VGND VGND VPWR VPWR sky130_fd_sc_hd__decap_3
XFILLER_11_206 VGND VGND VPWR VPWR sky130_fd_sc_hd__decap_3
XFILLER_11_228 VGND VGND VPWR VPWR sky130_fd_sc_hd__decap_3
XFILLER_24_589 VGND VGND VPWR VPWR sky130_fd_sc_hd__decap_3
X_4978_ _5092_/C _4973_/X _4975_/Y _6993_/D _4997_/A1 VGND VGND VPWR VPWR _4978_/X
+ sky130_fd_sc_hd__a32o_2
XFILLER_109_105 VGND VGND VPWR VPWR sky130_fd_sc_hd__decap_3
XFILLER_50_15 VGND VGND VPWR VPWR sky130_fd_sc_hd__decap_3
Xclkload4 clkload4/A VGND VGND VPWR VPWR clkload4/Y sky130_fd_sc_hd__clkinv_4
X_6717_ _7405_/CLK _6717_/D VGND VGND VPWR VPWR _6717_/Q sky130_fd_sc_hd__dfxtp_2
XFILLER_109_116 VGND VGND VPWR VPWR sky130_fd_sc_hd__decap_3
XFILLER_50_37 VGND VGND VPWR VPWR sky130_fd_sc_hd__decap_3
X_6648_ _6682_/A VGND VGND VPWR VPWR _6648_/Y sky130_fd_sc_hd__inv_2
XFILLER_109_149 VGND VGND VPWR VPWR sky130_fd_sc_hd__decap_3
XFILLER_3_405 VGND VGND VPWR VPWR sky130_fd_sc_hd__decap_3
X_6579_ _6611_/A VGND VGND VPWR VPWR _6579_/Y sky130_fd_sc_hd__inv_2
XFILLER_3_438 VGND VGND VPWR VPWR sky130_fd_sc_hd__decap_3
XFILLER_3_449 VGND VGND VPWR VPWR sky130_fd_sc_hd__decap_3
XFILLER_105_377 VGND VGND VPWR VPWR sky130_fd_sc_hd__decap_3
XFILLER_59_57 VGND VGND VPWR VPWR sky130_fd_sc_hd__decap_3
XFILLER_78_206 VGND VGND VPWR VPWR sky130_fd_sc_hd__decap_3
XFILLER_105_399 VGND VGND VPWR VPWR sky130_fd_sc_hd__decap_3
XFILLER_115_41 VGND VGND VPWR VPWR sky130_fd_sc_hd__decap_3
XFILLER_115_63 VGND VGND VPWR VPWR sky130_fd_sc_hd__decap_3
XFILLER_47_604 VGND VGND VPWR VPWR sky130_fd_sc_hd__decap_3
XFILLER_75_12 VGND VGND VPWR VPWR sky130_fd_sc_hd__decap_3
XFILLER_101_561 VGND VGND VPWR VPWR sky130_fd_sc_hd__fill_2
XFILLER_115_96 VGND VGND VPWR VPWR sky130_fd_sc_hd__decap_3
XFILLER_47_626 VGND VGND VPWR VPWR sky130_fd_sc_hd__decap_3
XFILLER_59_497 VGND VGND VPWR VPWR sky130_fd_sc_hd__decap_3
XFILLER_74_412 VGND VGND VPWR VPWR sky130_fd_sc_hd__decap_3
XTAP_TAPCELL_ROW_70_1096 VGND VPWR sky130_fd_sc_hd__tapvpwrvgnd_1
XFILLER_46_147 VGND VGND VPWR VPWR sky130_fd_sc_hd__decap_3
XFILLER_47_659 VGND VGND VPWR VPWR sky130_fd_sc_hd__decap_3
XFILLER_62_607 VGND VGND VPWR VPWR sky130_fd_sc_hd__decap_3
XFILLER_74_434 VGND VGND VPWR VPWR sky130_fd_sc_hd__decap_3
XFILLER_74_456 VGND VGND VPWR VPWR sky130_fd_sc_hd__decap_3
XFILLER_75_89 VGND VGND VPWR VPWR sky130_fd_sc_hd__decap_3
XFILLER_27_361 VGND VGND VPWR VPWR sky130_fd_sc_hd__fill_1
XFILLER_34_309 VGND VGND VPWR VPWR sky130_fd_sc_hd__decap_3
XFILLER_61_106 VGND VGND VPWR VPWR sky130_fd_sc_hd__decap_3
XFILLER_54_180 VGND VGND VPWR VPWR sky130_fd_sc_hd__decap_3
XFILLER_70_640 VGND VGND VPWR VPWR sky130_fd_sc_hd__decap_3
XFILLER_42_353 VGND VGND VPWR VPWR sky130_fd_sc_hd__decap_3
XFILLER_70_651 VGND VGND VPWR VPWR sky130_fd_sc_hd__decap_3
XFILLER_91_66 VGND VGND VPWR VPWR sky130_fd_sc_hd__decap_3
XTAP_TAPCELL_ROW_25_551 VGND VPWR sky130_fd_sc_hd__tapvpwrvgnd_1
XFILLER_15_589 VGND VGND VPWR VPWR sky130_fd_sc_hd__fill_1
XFILLER_24_60 VGND VGND VPWR VPWR sky130_fd_sc_hd__fill_1
XFILLER_70_684 VGND VGND VPWR VPWR sky130_fd_sc_hd__decap_3
XFILLER_91_99 VGND VGND VPWR VPWR sky130_fd_sc_hd__decap_3
XTAP_TAPCELL_ROW_53_893 VGND VPWR sky130_fd_sc_hd__tapvpwrvgnd_1
XTAP_TAPCELL_ROW_53_882 VGND VPWR sky130_fd_sc_hd__tapvpwrvgnd_1
XFILLER_24_82 VGND VGND VPWR VPWR sky130_fd_sc_hd__fill_2
XFILLER_30_559 VGND VGND VPWR VPWR sky130_fd_sc_hd__decap_3
XFILLER_109_650 VGND VGND VPWR VPWR sky130_fd_sc_hd__decap_3
XFILLER_10_283 VGND VGND VPWR VPWR sky130_fd_sc_hd__fill_1
XFILLER_116_609 VGND VGND VPWR VPWR sky130_fd_sc_hd__decap_3
XFILLER_115_108 VGND VGND VPWR VPWR sky130_fd_sc_hd__decap_3
XFILLER_115_119 VGND VGND VPWR VPWR sky130_fd_sc_hd__decap_3
XFILLER_69_217 VGND VGND VPWR VPWR sky130_fd_sc_hd__decap_3
XFILLER_2_460 VGND VGND VPWR VPWR sky130_fd_sc_hd__decap_3
XFILLER_34_6 VGND VGND VPWR VPWR sky130_fd_sc_hd__decap_3
XFILLER_69_228 VGND VGND VPWR VPWR sky130_fd_sc_hd__decap_3
XFILLER_97_559 VGND VGND VPWR VPWR sky130_fd_sc_hd__fill_1
XFILLER_1_20 VGND VGND VPWR VPWR sky130_fd_sc_hd__decap_3
XFILLER_77_272 VGND VGND VPWR VPWR sky130_fd_sc_hd__decap_3
XTAP_TAPCELL_ROW_88_1313 VGND VPWR sky130_fd_sc_hd__tapvpwrvgnd_1
XTAP_TAPCELL_ROW_88_1302 VGND VPWR sky130_fd_sc_hd__tapvpwrvgnd_1
XFILLER_1_53 VGND VGND VPWR VPWR sky130_fd_sc_hd__decap_3
XFILLER_37_147 VGND VGND VPWR VPWR sky130_fd_sc_hd__decap_3
XFILLER_38_648 VGND VGND VPWR VPWR sky130_fd_sc_hd__decap_3
XFILLER_65_445 VGND VGND VPWR VPWR sky130_fd_sc_hd__decap_3
XFILLER_1_75 VGND VGND VPWR VPWR sky130_fd_sc_hd__decap_3
XFILLER_37_169 VGND VGND VPWR VPWR sky130_fd_sc_hd__decap_3
XFILLER_53_607 VGND VGND VPWR VPWR sky130_fd_sc_hd__decap_3
XFILLER_53_629 VGND VGND VPWR VPWR sky130_fd_sc_hd__decap_3
XFILLER_65_489 VGND VGND VPWR VPWR sky130_fd_sc_hd__decap_3
XFILLER_33_320 VGND VGND VPWR VPWR sky130_fd_sc_hd__decap_3
XFILLER_46_681 VGND VGND VPWR VPWR sky130_fd_sc_hd__decap_3
X_4901_ _4901_/A0 _4899_/X _4901_/S VGND VGND VPWR VPWR _7268_/D sky130_fd_sc_hd__mux2_2
XFILLER_61_662 VGND VGND VPWR VPWR sky130_fd_sc_hd__decap_3
XFILLER_61_673 VGND VGND VPWR VPWR sky130_fd_sc_hd__decap_3
X_4832_ _4832_/A _5657_/A VGND VGND VPWR VPWR _4832_/X sky130_fd_sc_hd__or2_2
X_4763_ _4762_/A _4762_/B _4948_/A VGND VGND VPWR VPWR _4763_/X sky130_fd_sc_hd__a21o_2
X_6502_ _6567_/A VGND VGND VPWR VPWR _6502_/Y sky130_fd_sc_hd__inv_2
X_4694_ _7008_/Q _4728_/A VGND VGND VPWR VPWR _4694_/Y sky130_fd_sc_hd__nor2_2
X_3714_ _3735_/A _3741_/B _3746_/C VGND VGND VPWR VPWR _3714_/X sky130_fd_sc_hd__and3_2
XTAP_TAPCELL_ROW_99_1442 VGND VPWR sky130_fd_sc_hd__tapvpwrvgnd_1
X_6433_ _6562_/A VGND VGND VPWR VPWR _6433_/Y sky130_fd_sc_hd__inv_2
XFILLER_20_18 VGND VGND VPWR VPWR sky130_fd_sc_hd__decap_3
X_3645_ hold977/X _4791_/A1 _4664_/B VGND VGND VPWR VPWR _7406_/D sky130_fd_sc_hd__a21o_2
XFILLER_115_620 VGND VGND VPWR VPWR sky130_fd_sc_hd__decap_3
XFILLER_115_653 VGND VGND VPWR VPWR sky130_fd_sc_hd__decap_3
X_6364_ _6366_/A VGND VGND VPWR VPWR _6364_/Y sky130_fd_sc_hd__inv_2
X_3576_ _7252_/Q _3358_/X _3377_/X _7220_/Q _3575_/X VGND VGND VPWR VPWR _3591_/B
+ sky130_fd_sc_hd__a221oi_2
XFILLER_114_130 VGND VGND VPWR VPWR sky130_fd_sc_hd__decap_3
XFILLER_114_141 VGND VGND VPWR VPWR sky130_fd_sc_hd__decap_3
X_6295_ _6535_/A VGND VGND VPWR VPWR _6295_/Y sky130_fd_sc_hd__inv_2
X_5315_ _5315_/A0 _4878_/X _5315_/S VGND VGND VPWR VPWR _7173_/D sky130_fd_sc_hd__mux2_2
XFILLER_102_336 VGND VGND VPWR VPWR sky130_fd_sc_hd__decap_3
XFILLER_114_174 VGND VGND VPWR VPWR sky130_fd_sc_hd__decap_3
XFILLER_102_347 VGND VGND VPWR VPWR sky130_fd_sc_hd__decap_3
XPHY_EDGE_ROW_89_Right_89 VGND VGND VPWR VPWR sky130_fd_sc_hd__decap_3
XFILLER_29_626 VGND VGND VPWR VPWR sky130_fd_sc_hd__decap_3
X_5177_ _5177_/A _5182_/B VGND VGND VPWR VPWR _7239_/D sky130_fd_sc_hd__and2_2
XFILLER_110_380 VGND VGND VPWR VPWR sky130_fd_sc_hd__decap_3
XFILLER_28_125 VGND VGND VPWR VPWR sky130_fd_sc_hd__decap_3
XFILLER_28_147 VGND VGND VPWR VPWR sky130_fd_sc_hd__fill_2
X_4128_ _7331_/Q _3954_/S _4420_/B1 _7139_/Q VGND VGND VPWR VPWR _4128_/X sky130_fd_sc_hd__a22o_2
XFILLER_16_309 VGND VGND VPWR VPWR sky130_fd_sc_hd__decap_3
XFILLER_45_15 VGND VGND VPWR VPWR sky130_fd_sc_hd__decap_3
XFILLER_56_467 VGND VGND VPWR VPWR sky130_fd_sc_hd__decap_3
X_4059_ _7276_/Q _4437_/A2 _4056_/X _4058_/X VGND VGND VPWR VPWR _4059_/X sky130_fd_sc_hd__a211o_2
XFILLER_101_32 VGND VGND VPWR VPWR sky130_fd_sc_hd__fill_2
XFILLER_52_640 VGND VGND VPWR VPWR sky130_fd_sc_hd__decap_3
XFILLER_52_651 VGND VGND VPWR VPWR sky130_fd_sc_hd__decap_3
XFILLER_101_65 VGND VGND VPWR VPWR sky130_fd_sc_hd__decap_3
XFILLER_51_161 VGND VGND VPWR VPWR sky130_fd_sc_hd__decap_3
XFILLER_51_172 VGND VGND VPWR VPWR sky130_fd_sc_hd__decap_3
XFILLER_52_684 VGND VGND VPWR VPWR sky130_fd_sc_hd__decap_3
XTAP_TAPCELL_ROW_22_510 VGND VPWR sky130_fd_sc_hd__tapvpwrvgnd_1
XPHY_EDGE_ROW_98_Right_98 VGND VGND VPWR VPWR sky130_fd_sc_hd__decap_3
XFILLER_101_98 VGND VGND VPWR VPWR sky130_fd_sc_hd__decap_3
XFILLER_51_194 VGND VGND VPWR VPWR sky130_fd_sc_hd__decap_3
XFILLER_61_47 VGND VGND VPWR VPWR sky130_fd_sc_hd__fill_1
XTAP_TAPCELL_ROW_50_852 VGND VPWR sky130_fd_sc_hd__tapvpwrvgnd_1
XTAP_TAPCELL_ROW_22_521 VGND VPWR sky130_fd_sc_hd__tapvpwrvgnd_1
XFILLER_106_642 VGND VGND VPWR VPWR sky130_fd_sc_hd__fill_2
XFILLER_3_213 VGND VGND VPWR VPWR sky130_fd_sc_hd__decap_3
XFILLER_106_675 VGND VGND VPWR VPWR sky130_fd_sc_hd__decap_3
XFILLER_10_62 VGND VGND VPWR VPWR sky130_fd_sc_hd__decap_3
XTAP_TAPCELL_ROW_72_1114 VGND VPWR sky130_fd_sc_hd__tapvpwrvgnd_1
XPHY_EDGE_ROW_5_Left_122 VGND VGND VPWR VPWR sky130_fd_sc_hd__decap_3
XFILLER_105_196 VGND VGND VPWR VPWR sky130_fd_sc_hd__decap_3
XFILLER_86_88 VGND VGND VPWR VPWR sky130_fd_sc_hd__decap_3
XFILLER_94_529 VGND VGND VPWR VPWR sky130_fd_sc_hd__decap_3
XFILLER_101_380 VGND VGND VPWR VPWR sky130_fd_sc_hd__decap_3
XFILLER_19_136 VGND VGND VPWR VPWR sky130_fd_sc_hd__decap_3
XFILLER_19_60 VGND VGND VPWR VPWR sky130_fd_sc_hd__decap_3
XFILLER_59_294 VGND VGND VPWR VPWR sky130_fd_sc_hd__decap_3
XTAP_TAPCELL_ROW_58_952 VGND VPWR sky130_fd_sc_hd__tapvpwrvgnd_1
XFILLER_34_106 VGND VGND VPWR VPWR sky130_fd_sc_hd__decap_3
XFILLER_74_242 VGND VGND VPWR VPWR sky130_fd_sc_hd__decap_3
XFILLER_15_320 VGND VGND VPWR VPWR sky130_fd_sc_hd__decap_3
XFILLER_28_681 VGND VGND VPWR VPWR sky130_fd_sc_hd__decap_3
XFILLER_34_139 VGND VGND VPWR VPWR sky130_fd_sc_hd__fill_1
XFILLER_15_353 VGND VGND VPWR VPWR sky130_fd_sc_hd__decap_3
XFILLER_62_459 VGND VGND VPWR VPWR sky130_fd_sc_hd__fill_1
XTAP_TAPCELL_ROW_83_1243 VGND VPWR sky130_fd_sc_hd__tapvpwrvgnd_1
XFILLER_30_301 VGND VGND VPWR VPWR sky130_fd_sc_hd__decap_3
XFILLER_30_312 VGND VGND VPWR VPWR sky130_fd_sc_hd__decap_3
XFILLER_42_150 VGND VGND VPWR VPWR sky130_fd_sc_hd__decap_3
XFILLER_43_673 VGND VGND VPWR VPWR sky130_fd_sc_hd__decap_3
XFILLER_42_194 VGND VGND VPWR VPWR sky130_fd_sc_hd__fill_2
XFILLER_70_492 VGND VGND VPWR VPWR sky130_fd_sc_hd__decap_3
XFILLER_51_91 VGND VGND VPWR VPWR sky130_fd_sc_hd__decap_3
XFILLER_116_417 VGND VGND VPWR VPWR sky130_fd_sc_hd__decap_3
XFILLER_7_596 VGND VGND VPWR VPWR sky130_fd_sc_hd__decap_3
XFILLER_112_601 VGND VGND VPWR VPWR sky130_fd_sc_hd__decap_3
X_3361_ _3561_/A _3386_/B VGND VGND VPWR VPWR _3376_/B sky130_fd_sc_hd__and2_2
XTAP_TAPCELL_ROW_94_1383 VGND VPWR sky130_fd_sc_hd__tapvpwrvgnd_1
XFILLER_111_111 VGND VGND VPWR VPWR sky130_fd_sc_hd__fill_1
XFILLER_112_634 VGND VGND VPWR VPWR sky130_fd_sc_hd__decap_3
XFILLER_32_3 VGND VGND VPWR VPWR sky130_fd_sc_hd__decap_3
X_5100_ _5100_/A _5100_/B VGND VGND VPWR VPWR _5100_/Y sky130_fd_sc_hd__xnor2_2
XFILLER_111_122 VGND VGND VPWR VPWR sky130_fd_sc_hd__decap_3
XFILLER_112_645 VGND VGND VPWR VPWR sky130_fd_sc_hd__decap_3
XFILLER_112_678 VGND VGND VPWR VPWR sky130_fd_sc_hd__decap_3
X_5031_ _5032_/A _5031_/B VGND VGND VPWR VPWR _5031_/X sky130_fd_sc_hd__xor2_2
XFILLER_111_155 VGND VGND VPWR VPWR sky130_fd_sc_hd__decap_3
XFILLER_78_570 VGND VGND VPWR VPWR sky130_fd_sc_hd__fill_2
XFILLER_78_581 VGND VGND VPWR VPWR sky130_fd_sc_hd__decap_3
XFILLER_97_378 VGND VGND VPWR VPWR sky130_fd_sc_hd__decap_3
Xhold1208 _7130_/Q VGND VGND VPWR VPWR _5407_/A0 sky130_fd_sc_hd__dlygate4sd3_1
Xhold1219 _7128_/Q VGND VGND VPWR VPWR _5411_/A0 sky130_fd_sc_hd__dlygate4sd3_1
XFILLER_111_199 VGND VGND VPWR VPWR sky130_fd_sc_hd__decap_3
XFILLER_78_592 VGND VGND VPWR VPWR sky130_fd_sc_hd__fill_1
XPHY_EDGE_ROW_69_Left_186 VGND VGND VPWR VPWR sky130_fd_sc_hd__decap_3
XFILLER_19_681 VGND VGND VPWR VPWR sky130_fd_sc_hd__fill_1
X_6982_ _7265_/CLK _6982_/D _6262_/Y VGND VGND VPWR VPWR _6982_/Q sky130_fd_sc_hd__dfrtp_2
XTAP_TAPCELL_ROW_0_249 VGND VPWR sky130_fd_sc_hd__tapvpwrvgnd_1
XTAP_TAPCELL_ROW_0_238 VGND VPWR sky130_fd_sc_hd__tapvpwrvgnd_1
XFILLER_15_18 VGND VGND VPWR VPWR sky130_fd_sc_hd__decap_3
XFILLER_33_161 VGND VGND VPWR VPWR sky130_fd_sc_hd__decap_3
XTAP_TAPCELL_ROW_36_679 VGND VPWR sky130_fd_sc_hd__tapvpwrvgnd_1
X_4815_ _4812_/Y _4813_/Y _4814_/Y _4779_/X VGND VGND VPWR VPWR _4815_/X sky130_fd_sc_hd__o211a_2
XTAP_TAPCELL_ROW_103_1490 VGND VPWR sky130_fd_sc_hd__tapvpwrvgnd_1
X_4746_ _4764_/B _4069_/B _4744_/Y _4745_/Y _4852_/A VGND VGND VPWR VPWR _4746_/X
+ sky130_fd_sc_hd__o32a_2
X_4677_ _6989_/Q _4677_/B VGND VGND VPWR VPWR _5036_/A sky130_fd_sc_hd__and2_2
XPHY_EDGE_ROW_78_Left_195 VGND VGND VPWR VPWR sky130_fd_sc_hd__decap_3
XFILLER_103_9 VGND VGND VPWR VPWR sky130_fd_sc_hd__decap_3
XFILLER_107_439 VGND VGND VPWR VPWR sky130_fd_sc_hd__decap_3
X_7396_ _7398_/CLK _7396_/D _6676_/Y VGND VGND VPWR VPWR _7396_/Q sky130_fd_sc_hd__dfrtp_2
X_6416_ _6608_/A VGND VGND VPWR VPWR _6416_/Y sky130_fd_sc_hd__inv_2
X_6347_ _6347_/A VGND VGND VPWR VPWR _6347_/Y sky130_fd_sc_hd__inv_2
XFILLER_103_623 VGND VGND VPWR VPWR sky130_fd_sc_hd__decap_3
XFILLER_88_323 VGND VGND VPWR VPWR sky130_fd_sc_hd__decap_3
X_3559_ _3553_/X _3557_/X _3558_/X _3590_/A VGND VGND VPWR VPWR _4295_/B sky130_fd_sc_hd__o211a_2
XTAP_TAPCELL_ROW_8_349 VGND VPWR sky130_fd_sc_hd__tapvpwrvgnd_1
XFILLER_102_144 VGND VGND VPWR VPWR sky130_fd_sc_hd__fill_2
XFILLER_103_656 VGND VGND VPWR VPWR sky130_fd_sc_hd__decap_3
X_6278_ _6280_/A VGND VGND VPWR VPWR _6278_/Y sky130_fd_sc_hd__inv_2
XFILLER_48_209 VGND VGND VPWR VPWR sky130_fd_sc_hd__fill_2
XFILLER_88_389 VGND VGND VPWR VPWR sky130_fd_sc_hd__decap_3
X_5229_ _5362_/C _5229_/B _5229_/C VGND VGND VPWR VPWR _5245_/S sky130_fd_sc_hd__and3b_2
XFILLER_29_423 VGND VGND VPWR VPWR sky130_fd_sc_hd__decap_3
XFILLER_17_607 VGND VGND VPWR VPWR sky130_fd_sc_hd__decap_3
XFILLER_29_467 VGND VGND VPWR VPWR sky130_fd_sc_hd__decap_3
XFILLER_56_242 VGND VGND VPWR VPWR sky130_fd_sc_hd__decap_3
XFILLER_56_253 VGND VGND VPWR VPWR sky130_fd_sc_hd__decap_3
XFILLER_56_69 VGND VGND VPWR VPWR sky130_fd_sc_hd__decap_3
XTAP_TAPCELL_ROW_55_911 VGND VPWR sky130_fd_sc_hd__tapvpwrvgnd_1
XFILLER_112_20 VGND VGND VPWR VPWR sky130_fd_sc_hd__decap_3
XFILLER_16_128 VGND VGND VPWR VPWR sky130_fd_sc_hd__decap_3
XFILLER_56_286 VGND VGND VPWR VPWR sky130_fd_sc_hd__fill_1
XFILLER_71_223 VGND VGND VPWR VPWR sky130_fd_sc_hd__fill_1
XTAP_TAPCELL_ROW_106_1519 VGND VPWR sky130_fd_sc_hd__tapvpwrvgnd_1
XFILLER_112_53 VGND VGND VPWR VPWR sky130_fd_sc_hd__decap_3
XFILLER_72_24 VGND VGND VPWR VPWR sky130_fd_sc_hd__fill_1
XFILLER_112_97 VGND VGND VPWR VPWR sky130_fd_sc_hd__decap_3
XFILLER_12_301 VGND VGND VPWR VPWR sky130_fd_sc_hd__decap_3
XFILLER_12_312 VGND VGND VPWR VPWR sky130_fd_sc_hd__decap_3
XFILLER_31_109 VGND VGND VPWR VPWR sky130_fd_sc_hd__decap_3
XFILLER_12_334 VGND VGND VPWR VPWR sky130_fd_sc_hd__decap_3
XFILLER_24_194 VGND VGND VPWR VPWR sky130_fd_sc_hd__fill_2
XFILLER_72_79 VGND VGND VPWR VPWR sky130_fd_sc_hd__decap_3
XFILLER_40_676 VGND VGND VPWR VPWR sky130_fd_sc_hd__decap_3
XFILLER_8_305 VGND VGND VPWR VPWR sky130_fd_sc_hd__decap_3
XFILLER_4_533 VGND VGND VPWR VPWR sky130_fd_sc_hd__decap_3
XFILLER_113_409 VGND VGND VPWR VPWR sky130_fd_sc_hd__decap_3
XFILLER_97_21 VGND VGND VPWR VPWR sky130_fd_sc_hd__decap_3
XFILLER_106_472 VGND VGND VPWR VPWR sky130_fd_sc_hd__decap_3
XFILLER_79_312 VGND VGND VPWR VPWR sky130_fd_sc_hd__decap_3
XFILLER_39_209 VGND VGND VPWR VPWR sky130_fd_sc_hd__decap_3
XFILLER_94_304 VGND VGND VPWR VPWR sky130_fd_sc_hd__fill_1
XFILLER_94_326 VGND VGND VPWR VPWR sky130_fd_sc_hd__fill_1
XFILLER_47_231 VGND VGND VPWR VPWR sky130_fd_sc_hd__fill_1
XFILLER_94_359 VGND VGND VPWR VPWR sky130_fd_sc_hd__decap_3
XFILLER_62_223 VGND VGND VPWR VPWR sky130_fd_sc_hd__fill_1
XFILLER_75_584 VGND VGND VPWR VPWR sky130_fd_sc_hd__decap_3
XFILLER_50_407 VGND VGND VPWR VPWR sky130_fd_sc_hd__decap_3
XFILLER_62_256 VGND VGND VPWR VPWR sky130_fd_sc_hd__decap_3
XFILLER_15_161 VGND VGND VPWR VPWR sky130_fd_sc_hd__decap_3
XFILLER_15_183 VGND VGND VPWR VPWR sky130_fd_sc_hd__fill_2
XFILLER_30_120 VGND VGND VPWR VPWR sky130_fd_sc_hd__decap_3
XTAP_TAPCELL_ROW_33_649 VGND VPWR sky130_fd_sc_hd__tapvpwrvgnd_1
XFILLER_30_186 VGND VGND VPWR VPWR sky130_fd_sc_hd__decap_3
XFILLER_7_30 VGND VGND VPWR VPWR sky130_fd_sc_hd__decap_3
XTAP_TAPCELL_ROW_96_1401 VGND VPWR sky130_fd_sc_hd__tapvpwrvgnd_1
XFILLER_116_203 VGND VGND VPWR VPWR sky130_fd_sc_hd__decap_3
XFILLER_7_63 VGND VGND VPWR VPWR sky130_fd_sc_hd__decap_3
XFILLER_116_225 VGND VGND VPWR VPWR sky130_fd_sc_hd__decap_3
XFILLER_7_393 VGND VGND VPWR VPWR sky130_fd_sc_hd__decap_3
XFILLER_7_96 VGND VGND VPWR VPWR sky130_fd_sc_hd__decap_3
X_7250_ _7352_/CLK _7250_/D _6530_/Y VGND VGND VPWR VPWR _7250_/Q sky130_fd_sc_hd__dfrtp_2
X_4462_ _3621_/B _3618_/X _3541_/X VGND VGND VPWR VPWR _4462_/Y sky130_fd_sc_hd__o21ai_2
X_3413_ _7155_/Q _4334_/B1 _3410_/X _3412_/X VGND VGND VPWR VPWR _3413_/X sky130_fd_sc_hd__a211o_2
X_7181_ _7374_/CLK _7181_/D _6461_/Y VGND VGND VPWR VPWR _7181_/Q sky130_fd_sc_hd__dfrtp_2
X_4393_ _7305_/Q _4901_/S _4434_/A2 _7113_/Q _4392_/X VGND VGND VPWR VPWR _4393_/X
+ sky130_fd_sc_hd__a221o_2
XFILLER_98_621 VGND VGND VPWR VPWR sky130_fd_sc_hd__decap_3
XFILLER_97_120 VGND VGND VPWR VPWR sky130_fd_sc_hd__decap_3
XFILLER_97_142 VGND VGND VPWR VPWR sky130_fd_sc_hd__decap_3
X_3344_ _3519_/B _5118_/D VGND VGND VPWR VPWR _3344_/Y sky130_fd_sc_hd__nor2_2
XTAP_TAPCELL_ROW_5_308 VGND VPWR sky130_fd_sc_hd__tapvpwrvgnd_1
XFILLER_98_654 VGND VGND VPWR VPWR sky130_fd_sc_hd__decap_3
XFILLER_100_626 VGND VGND VPWR VPWR sky130_fd_sc_hd__decap_3
XFILLER_112_486 VGND VGND VPWR VPWR sky130_fd_sc_hd__decap_3
Xhold1005 _7263_/Q VGND VGND VPWR VPWR _4979_/A0 sky130_fd_sc_hd__dlygate4sd3_1
XFILLER_100_648 VGND VGND VPWR VPWR sky130_fd_sc_hd__decap_3
Xhold1016 _7191_/Q VGND VGND VPWR VPWR _5278_/A0 sky130_fd_sc_hd__dlygate4sd3_1
Xhold1027 _7194_/Q VGND VGND VPWR VPWR _5272_/A0 sky130_fd_sc_hd__dlygate4sd3_1
Xhold1038 _7199_/Q VGND VGND VPWR VPWR _5262_/A0 sky130_fd_sc_hd__dlygate4sd3_1
Xhold1049 _7313_/Q VGND VGND VPWR VPWR _4532_/A0 sky130_fd_sc_hd__dlygate4sd3_1
X_5014_ _6990_/Q _5014_/B VGND VGND VPWR VPWR _5015_/C sky130_fd_sc_hd__or2_2
XFILLER_38_253 VGND VGND VPWR VPWR sky130_fd_sc_hd__decap_3
XFILLER_38_275 VGND VGND VPWR VPWR sky130_fd_sc_hd__decap_3
XFILLER_66_595 VGND VGND VPWR VPWR sky130_fd_sc_hd__decap_3
XFILLER_53_234 VGND VGND VPWR VPWR sky130_fd_sc_hd__decap_3
X_6965_ _6965_/CLK _6965_/D VGND VGND VPWR VPWR _6965_/Q sky130_fd_sc_hd__dfxtp_2
XFILLER_34_470 VGND VGND VPWR VPWR sky130_fd_sc_hd__decap_3
XFILLER_41_418 VGND VGND VPWR VPWR sky130_fd_sc_hd__decap_3
XFILLER_53_267 VGND VGND VPWR VPWR sky130_fd_sc_hd__decap_3
XFILLER_81_598 VGND VGND VPWR VPWR sky130_fd_sc_hd__decap_3
X_6896_ _6944_/CLK _6896_/D VGND VGND VPWR VPWR _6896_/Q sky130_fd_sc_hd__dfxtp_2
XFILLER_42_27 VGND VGND VPWR VPWR sky130_fd_sc_hd__fill_1
XPHY_EDGE_ROW_86_Left_203 VGND VGND VPWR VPWR sky130_fd_sc_hd__decap_3
XFILLER_5_319 VGND VGND VPWR VPWR sky130_fd_sc_hd__decap_3
X_4729_ _4836_/S _4729_/B VGND VGND VPWR VPWR _4729_/Y sky130_fd_sc_hd__nand2_2
XFILLER_107_225 VGND VGND VPWR VPWR sky130_fd_sc_hd__decap_3
XFILLER_107_20 VGND VGND VPWR VPWR sky130_fd_sc_hd__decap_3
XFILLER_89_632 VGND VGND VPWR VPWR sky130_fd_sc_hd__decap_3
X_7379_ _7384_/CLK _7379_/D _6659_/Y VGND VGND VPWR VPWR _7379_/Q sky130_fd_sc_hd__dfrtp_2
Xhold850 _7069_/Q VGND VGND VPWR VPWR _7069_/D sky130_fd_sc_hd__dlygate4sd3_1
Xhold861 _7056_/Q VGND VGND VPWR VPWR _7056_/D sky130_fd_sc_hd__dlygate4sd3_1
Xhold872 _7091_/Q VGND VGND VPWR VPWR _7091_/D sky130_fd_sc_hd__dlygate4sd3_1
XFILLER_107_53 VGND VGND VPWR VPWR sky130_fd_sc_hd__decap_3
XFILLER_107_75 VGND VGND VPWR VPWR sky130_fd_sc_hd__decap_3
XFILLER_88_120 VGND VGND VPWR VPWR sky130_fd_sc_hd__decap_3
XFILLER_89_665 VGND VGND VPWR VPWR sky130_fd_sc_hd__decap_3
Xhold883 _7080_/Q VGND VGND VPWR VPWR _7080_/D sky130_fd_sc_hd__dlygate4sd3_1
Xhold894 _7075_/Q VGND VGND VPWR VPWR _7075_/D sky130_fd_sc_hd__dlygate4sd3_1
XFILLER_103_464 VGND VGND VPWR VPWR sky130_fd_sc_hd__decap_3
XFILLER_103_486 VGND VGND VPWR VPWR sky130_fd_sc_hd__decap_3
XFILLER_67_24 VGND VGND VPWR VPWR sky130_fd_sc_hd__decap_3
XFILLER_67_57 VGND VGND VPWR VPWR sky130_fd_sc_hd__fill_1
XFILLER_89_676 VGND VGND VPWR VPWR sky130_fd_sc_hd__decap_3
XPHY_EDGE_ROW_95_Left_212 VGND VGND VPWR VPWR sky130_fd_sc_hd__decap_3
XFILLER_29_231 VGND VGND VPWR VPWR sky130_fd_sc_hd__decap_3
XFILLER_29_242 VGND VGND VPWR VPWR sky130_fd_sc_hd__decap_3
XFILLER_29_264 VGND VGND VPWR VPWR sky130_fd_sc_hd__decap_3
XFILLER_57_573 VGND VGND VPWR VPWR sky130_fd_sc_hd__decap_3
XFILLER_83_12 VGND VGND VPWR VPWR sky130_fd_sc_hd__decap_3
XFILLER_44_234 VGND VGND VPWR VPWR sky130_fd_sc_hd__fill_1
XTAP_TAPCELL_ROW_67_1057 VGND VPWR sky130_fd_sc_hd__tapvpwrvgnd_1
XFILLER_13_610 VGND VGND VPWR VPWR sky130_fd_sc_hd__decap_3
XFILLER_16_50 VGND VGND VPWR VPWR sky130_fd_sc_hd__decap_3
XFILLER_32_407 VGND VGND VPWR VPWR sky130_fd_sc_hd__decap_3
XFILLER_32_429 VGND VGND VPWR VPWR sky130_fd_sc_hd__decap_3
XFILLER_72_587 VGND VGND VPWR VPWR sky130_fd_sc_hd__fill_1
XFILLER_16_83 VGND VGND VPWR VPWR sky130_fd_sc_hd__fill_1
XTAP_TAPCELL_ROW_80_1213 VGND VPWR sky130_fd_sc_hd__tapvpwrvgnd_1
XFILLER_13_676 VGND VGND VPWR VPWR sky130_fd_sc_hd__decap_3
XTAP_TAPCELL_ROW_30_608 VGND VPWR sky130_fd_sc_hd__tapvpwrvgnd_1
XFILLER_12_186 VGND VGND VPWR VPWR sky130_fd_sc_hd__decap_3
XFILLER_40_473 VGND VGND VPWR VPWR sky130_fd_sc_hd__decap_3
XFILLER_8_124 VGND VGND VPWR VPWR sky130_fd_sc_hd__decap_3
XFILLER_9_669 VGND VGND VPWR VPWR sky130_fd_sc_hd__decap_3
XFILLER_12_197 VGND VGND VPWR VPWR sky130_fd_sc_hd__decap_3
XFILLER_8_168 VGND VGND VPWR VPWR sky130_fd_sc_hd__fill_2
XFILLER_66_9 VGND VGND VPWR VPWR sky130_fd_sc_hd__decap_3
XTAP_TAPCELL_ROW_10_376 VGND VPWR sky130_fd_sc_hd__tapvpwrvgnd_1
XFILLER_4_352 VGND VGND VPWR VPWR sky130_fd_sc_hd__decap_3
XTAP_TAPCELL_ROW_78_1186 VGND VPWR sky130_fd_sc_hd__tapvpwrvgnd_1
XFILLER_113_217 VGND VGND VPWR VPWR sky130_fd_sc_hd__decap_3
XFILLER_113_228 VGND VGND VPWR VPWR sky130_fd_sc_hd__decap_3
XFILLER_106_280 VGND VGND VPWR VPWR sky130_fd_sc_hd__decap_3
XTAP_TAPCELL_ROW_91_1342 VGND VPWR sky130_fd_sc_hd__tapvpwrvgnd_1
XFILLER_79_175 VGND VGND VPWR VPWR sky130_fd_sc_hd__decap_3
XFILLER_0_580 VGND VGND VPWR VPWR sky130_fd_sc_hd__decap_3
XFILLER_67_337 VGND VGND VPWR VPWR sky130_fd_sc_hd__decap_3
XFILLER_94_123 VGND VGND VPWR VPWR sky130_fd_sc_hd__decap_3
XFILLER_95_635 VGND VGND VPWR VPWR sky130_fd_sc_hd__decap_3
XFILLER_48_562 VGND VGND VPWR VPWR sky130_fd_sc_hd__decap_3
XFILLER_95_668 VGND VGND VPWR VPWR sky130_fd_sc_hd__decap_3
XFILLER_95_679 VGND VGND VPWR VPWR sky130_fd_sc_hd__decap_3
XTAP_TAPCELL_ROW_38_708 VGND VPWR sky130_fd_sc_hd__tapvpwrvgnd_1
XFILLER_63_521 VGND VGND VPWR VPWR sky130_fd_sc_hd__decap_3
XFILLER_75_370 VGND VGND VPWR VPWR sky130_fd_sc_hd__decap_3
XFILLER_35_223 VGND VGND VPWR VPWR sky130_fd_sc_hd__fill_1
XFILLER_35_234 VGND VGND VPWR VPWR sky130_fd_sc_hd__decap_3
XFILLER_35_267 VGND VGND VPWR VPWR sky130_fd_sc_hd__decap_3
XFILLER_63_598 VGND VGND VPWR VPWR sky130_fd_sc_hd__decap_3
XFILLER_90_351 VGND VGND VPWR VPWR sky130_fd_sc_hd__fill_2
X_6750_ _6978_/CLK _6750_/D VGND VGND VPWR VPWR _6750_/Q sky130_fd_sc_hd__dfxtp_2
XTAP_TAPCELL_ROW_18_465 VGND VPWR sky130_fd_sc_hd__tapvpwrvgnd_1
XFILLER_16_470 VGND VGND VPWR VPWR sky130_fd_sc_hd__decap_3
X_5701_ _7356_/Q hold919/X _5706_/S VGND VGND VPWR VPWR _6700_/D sky130_fd_sc_hd__mux2_2
X_3962_ _7359_/Q _4505_/A0 _3962_/S VGND VGND VPWR VPWR _7359_/D sky130_fd_sc_hd__mux2_2
XFILLER_50_259 VGND VGND VPWR VPWR sky130_fd_sc_hd__decap_3
X_6681_ _6682_/A VGND VGND VPWR VPWR _6681_/Y sky130_fd_sc_hd__inv_2
X_3893_ _6759_/Q _3913_/A2 _3893_/B1 _6753_/Q _3892_/X VGND VGND VPWR VPWR _3893_/X
+ sky130_fd_sc_hd__a221o_2
X_5632_ _5632_/A VGND VGND VPWR VPWR _5633_/A sky130_fd_sc_hd__inv_2
X_5563_ hold968/X _4909_/A _4729_/B VGND VGND VPWR VPWR _7053_/D sky130_fd_sc_hd__a21bo_2
XFILLER_8_680 VGND VGND VPWR VPWR sky130_fd_sc_hd__decap_3
X_7302_ _7334_/CLK _7302_/D _6582_/Y VGND VGND VPWR VPWR _7302_/Q sky130_fd_sc_hd__dfrtp_2
XFILLER_104_228 VGND VGND VPWR VPWR sky130_fd_sc_hd__fill_1
X_7233_ _7397_/CLK _7233_/D _6513_/Y VGND VGND VPWR VPWR _7233_/Q sky130_fd_sc_hd__dfrtp_2
X_4445_ _4813_/A _4813_/B VGND VGND VPWR VPWR _4814_/B sky130_fd_sc_hd__nor2_2
X_7164_ _7294_/CLK _7164_/D _6444_/Y VGND VGND VPWR VPWR _7164_/Q sky130_fd_sc_hd__dfrtp_2
X_4376_ _4376_/A _4376_/B _4376_/C _4273_/D VGND VGND VPWR VPWR _4376_/X sky130_fd_sc_hd__or4b_2
XFILLER_100_401 VGND VGND VPWR VPWR sky130_fd_sc_hd__decap_3
XFILLER_112_261 VGND VGND VPWR VPWR sky130_fd_sc_hd__decap_3
XFILLER_58_315 VGND VGND VPWR VPWR sky130_fd_sc_hd__decap_3
XFILLER_86_624 VGND VGND VPWR VPWR sky130_fd_sc_hd__decap_3
X_3327_ _3327_/A _3353_/A VGND VGND VPWR VPWR _3328_/B sky130_fd_sc_hd__nor2_2
XFILLER_98_473 VGND VGND VPWR VPWR sky130_fd_sc_hd__decap_3
XFILLER_112_294 VGND VGND VPWR VPWR sky130_fd_sc_hd__fill_1
XFILLER_58_348 VGND VGND VPWR VPWR sky130_fd_sc_hd__fill_1
XFILLER_85_134 VGND VGND VPWR VPWR sky130_fd_sc_hd__decap_3
XFILLER_86_657 VGND VGND VPWR VPWR sky130_fd_sc_hd__decap_3
X_7095_ clkload5/A _7095_/D _6375_/Y VGND VGND VPWR VPWR _7095_/Q sky130_fd_sc_hd__dfrtp_2
XFILLER_37_27 VGND VGND VPWR VPWR sky130_fd_sc_hd__decap_3
XFILLER_100_489 VGND VGND VPWR VPWR sky130_fd_sc_hd__decap_3
XFILLER_26_212 VGND VGND VPWR VPWR sky130_fd_sc_hd__decap_3
XFILLER_39_595 VGND VGND VPWR VPWR sky130_fd_sc_hd__decap_3
XFILLER_66_381 VGND VGND VPWR VPWR sky130_fd_sc_hd__fill_1
XFILLER_73_318 VGND VGND VPWR VPWR sky130_fd_sc_hd__decap_3
XFILLER_85_178 VGND VGND VPWR VPWR sky130_fd_sc_hd__decap_3
XFILLER_94_690 VGND VGND VPWR VPWR sky130_fd_sc_hd__fill_2
XFILLER_53_15 VGND VGND VPWR VPWR sky130_fd_sc_hd__decap_3
XFILLER_54_598 VGND VGND VPWR VPWR sky130_fd_sc_hd__decap_3
XFILLER_81_362 VGND VGND VPWR VPWR sky130_fd_sc_hd__fill_2
X_6948_ _6965_/CLK _6948_/D VGND VGND VPWR VPWR _6948_/Q sky130_fd_sc_hd__dfxtp_2
X_6879_ _7392_/CLK _6879_/D VGND VGND VPWR VPWR _6879_/Q sky130_fd_sc_hd__dfxtp_2
XFILLER_10_668 VGND VGND VPWR VPWR sky130_fd_sc_hd__decap_3
XFILLER_6_606 VGND VGND VPWR VPWR sky130_fd_sc_hd__decap_3
XFILLER_5_105 VGND VGND VPWR VPWR sky130_fd_sc_hd__decap_3
XFILLER_5_116 VGND VGND VPWR VPWR sky130_fd_sc_hd__decap_3
XFILLER_6_628 VGND VGND VPWR VPWR sky130_fd_sc_hd__fill_2
XFILLER_5_149 VGND VGND VPWR VPWR sky130_fd_sc_hd__decap_3
XTAP_TAPCELL_ROW_114_1618 VGND VPWR sky130_fd_sc_hd__tapvpwrvgnd_1
XFILLER_108_589 VGND VGND VPWR VPWR sky130_fd_sc_hd__decap_3
XFILLER_78_45 VGND VGND VPWR VPWR sky130_fd_sc_hd__decap_3
Xhold680 _6968_/Q VGND VGND VPWR VPWR _6968_/D sky130_fd_sc_hd__dlygate4sd3_1
XFILLER_103_250 VGND VGND VPWR VPWR sky130_fd_sc_hd__decap_3
XFILLER_110_209 VGND VGND VPWR VPWR sky130_fd_sc_hd__fill_1
XFILLER_49_304 VGND VGND VPWR VPWR sky130_fd_sc_hd__decap_3
XFILLER_77_624 VGND VGND VPWR VPWR sky130_fd_sc_hd__decap_3
Xhold691 _6811_/Q VGND VGND VPWR VPWR _6811_/D sky130_fd_sc_hd__dlygate4sd3_1
XFILLER_103_272 VGND VGND VPWR VPWR sky130_fd_sc_hd__decap_3
XFILLER_1_388 VGND VGND VPWR VPWR sky130_fd_sc_hd__decap_3
XFILLER_1_399 VGND VGND VPWR VPWR sky130_fd_sc_hd__decap_3
XFILLER_49_337 VGND VGND VPWR VPWR sky130_fd_sc_hd__decap_3
XFILLER_77_657 VGND VGND VPWR VPWR sky130_fd_sc_hd__decap_3
XFILLER_76_156 VGND VGND VPWR VPWR sky130_fd_sc_hd__decap_3
XFILLER_77_679 VGND VGND VPWR VPWR sky130_fd_sc_hd__decap_3
XFILLER_57_370 VGND VGND VPWR VPWR sky130_fd_sc_hd__decap_3
XFILLER_64_318 VGND VGND VPWR VPWR sky130_fd_sc_hd__decap_3
XFILLER_92_638 VGND VGND VPWR VPWR sky130_fd_sc_hd__decap_3
XFILLER_94_77 VGND VGND VPWR VPWR sky130_fd_sc_hd__decap_3
XFILLER_17_234 VGND VGND VPWR VPWR sky130_fd_sc_hd__decap_3
XFILLER_27_60 VGND VGND VPWR VPWR sky130_fd_sc_hd__decap_3
XFILLER_91_137 VGND VGND VPWR VPWR sky130_fd_sc_hd__decap_3
XFILLER_94_88 VGND VGND VPWR VPWR sky130_fd_sc_hd__decap_3
XFILLER_17_278 VGND VGND VPWR VPWR sky130_fd_sc_hd__fill_2
XFILLER_27_93 VGND VGND VPWR VPWR sky130_fd_sc_hd__decap_3
XFILLER_72_351 VGND VGND VPWR VPWR sky130_fd_sc_hd__decap_3
XFILLER_72_373 VGND VGND VPWR VPWR sky130_fd_sc_hd__decap_3
XFILLER_32_215 VGND VGND VPWR VPWR sky130_fd_sc_hd__decap_3
XTAP_TAPCELL_ROW_15_435 VGND VPWR sky130_fd_sc_hd__tapvpwrvgnd_1
XFILLER_60_579 VGND VGND VPWR VPWR sky130_fd_sc_hd__decap_3
XTAP_TAPCELL_ROW_43_766 VGND VPWR sky130_fd_sc_hd__tapvpwrvgnd_1
XFILLER_9_411 VGND VGND VPWR VPWR sky130_fd_sc_hd__decap_3
XFILLER_9_466 VGND VGND VPWR VPWR sky130_fd_sc_hd__fill_2
XFILLER_64_6 VGND VGND VPWR VPWR sky130_fd_sc_hd__decap_3
XFILLER_99_215 VGND VGND VPWR VPWR sky130_fd_sc_hd__decap_3
XFILLER_114_548 VGND VGND VPWR VPWR sky130_fd_sc_hd__decap_3
X_4230_ _7227_/Q _4331_/A2 _5157_/S _7291_/Q _4229_/X VGND VGND VPWR VPWR _4230_/X
+ sky130_fd_sc_hd__a221o_2
XFILLER_99_248 VGND VGND VPWR VPWR sky130_fd_sc_hd__decap_3
XFILLER_4_53 VGND VGND VPWR VPWR sky130_fd_sc_hd__decap_3
X_4161_ _7265_/Q _4418_/A2 _4349_/B1 _7233_/Q _4160_/X VGND VGND VPWR VPWR _4161_/X
+ sky130_fd_sc_hd__a221o_2
XFILLER_4_97 VGND VGND VPWR VPWR sky130_fd_sc_hd__decap_3
XFILLER_68_635 VGND VGND VPWR VPWR sky130_fd_sc_hd__decap_3
XFILLER_68_657 VGND VGND VPWR VPWR sky130_fd_sc_hd__decap_3
XFILLER_67_134 VGND VGND VPWR VPWR sky130_fd_sc_hd__decap_3
XFILLER_67_156 VGND VGND VPWR VPWR sky130_fd_sc_hd__decap_3
XFILLER_95_443 VGND VGND VPWR VPWR sky130_fd_sc_hd__decap_3
X_4092_ _7366_/Q _4435_/B1 _4436_/B1 _7174_/Q _4091_/X VGND VGND VPWR VPWR _4092_/X
+ sky130_fd_sc_hd__a221o_2
XFILLER_36_521 VGND VGND VPWR VPWR sky130_fd_sc_hd__decap_3
XFILLER_55_318 VGND VGND VPWR VPWR sky130_fd_sc_hd__decap_3
XFILLER_83_638 VGND VGND VPWR VPWR sky130_fd_sc_hd__decap_3
XFILLER_48_392 VGND VGND VPWR VPWR sky130_fd_sc_hd__decap_3
XFILLER_76_690 VGND VGND VPWR VPWR sky130_fd_sc_hd__fill_2
XFILLER_51_513 VGND VGND VPWR VPWR sky130_fd_sc_hd__decap_3
XFILLER_63_373 VGND VGND VPWR VPWR sky130_fd_sc_hd__decap_3
XFILLER_91_671 VGND VGND VPWR VPWR sky130_fd_sc_hd__fill_1
XFILLER_91_682 VGND VGND VPWR VPWR sky130_fd_sc_hd__decap_3
Xplace340 _5396_/S VGND VGND VPWR VPWR _5429_/S sky130_fd_sc_hd__buf_2
X_6802_ _7405_/CLK _6802_/D VGND VGND VPWR VPWR _6802_/Q sky130_fd_sc_hd__dfxtp_2
XFILLER_90_192 VGND VGND VPWR VPWR sky130_fd_sc_hd__decap_3
Xplace373 _3864_/S VGND VGND VPWR VPWR _3896_/B1 sky130_fd_sc_hd__buf_2
Xplace362 _3409_/X VGND VGND VPWR VPWR _4334_/B1 sky130_fd_sc_hd__buf_2
Xplace351 _3417_/X VGND VGND VPWR VPWR _4351_/A2 sky130_fd_sc_hd__buf_2
X_4994_ _5072_/A _4994_/A2 _4987_/A _5033_/B2 VGND VGND VPWR VPWR _4994_/X sky130_fd_sc_hd__a22o_2
XFILLER_23_18 VGND VGND VPWR VPWR sky130_fd_sc_hd__decap_3
Xplace384 _5221_/B VGND VGND VPWR VPWR _5225_/B sky130_fd_sc_hd__buf_2
Xplace395 _7412_/A VGND VGND VPWR VPWR _5360_/S sky130_fd_sc_hd__buf_2
X_6733_ _6970_/CLK _6733_/D VGND VGND VPWR VPWR _6733_/Q sky130_fd_sc_hd__dfxtp_2
X_3945_ _7367_/Q _4488_/A0 _3945_/S VGND VGND VPWR VPWR _7367_/D sky130_fd_sc_hd__mux2_2
X_6664_ _6664_/A VGND VGND VPWR VPWR _6664_/Y sky130_fd_sc_hd__inv_2
X_5615_ _5615_/A _5622_/B VGND VGND VPWR VPWR _7020_/D sky130_fd_sc_hd__or2_2
X_3876_ _6858_/Q _3889_/A2 _3888_/B1 _6898_/Q VGND VGND VPWR VPWR _3876_/X sky130_fd_sc_hd__a22o_2
X_6595_ _6635_/A VGND VGND VPWR VPWR _6595_/Y sky130_fd_sc_hd__inv_2
X_7216_ _7387_/CLK _7216_/D _6496_/Y VGND VGND VPWR VPWR _7216_/Q sky130_fd_sc_hd__dfrtp_2
X_4428_ _7335_/Q _3945_/S _5229_/C _7143_/Q VGND VGND VPWR VPWR _4428_/X sky130_fd_sc_hd__a22o_2
XFILLER_48_15 VGND VGND VPWR VPWR sky130_fd_sc_hd__decap_3
XFILLER_59_602 VGND VGND VPWR VPWR sky130_fd_sc_hd__decap_3
XFILLER_113_570 VGND VGND VPWR VPWR sky130_fd_sc_hd__decap_3
XFILLER_58_123 VGND VGND VPWR VPWR sky130_fd_sc_hd__fill_1
XFILLER_59_635 VGND VGND VPWR VPWR sky130_fd_sc_hd__decap_3
X_7147_ _7310_/CLK _7147_/D _6427_/Y VGND VGND VPWR VPWR _7147_/Q sky130_fd_sc_hd__dfrtp_2
X_4359_ _4367_/C _4367_/A _4367_/B VGND VGND VPWR VPWR _5071_/B sky130_fd_sc_hd__nand3b_2
XFILLER_98_281 VGND VGND VPWR VPWR sky130_fd_sc_hd__decap_3
XFILLER_100_253 VGND VGND VPWR VPWR sky130_fd_sc_hd__decap_3
XFILLER_104_21 VGND VGND VPWR VPWR sky130_fd_sc_hd__decap_3
XFILLER_58_156 VGND VGND VPWR VPWR sky130_fd_sc_hd__decap_3
XFILLER_59_668 VGND VGND VPWR VPWR sky130_fd_sc_hd__decap_3
XFILLER_59_679 VGND VGND VPWR VPWR sky130_fd_sc_hd__decap_3
XFILLER_86_443 VGND VGND VPWR VPWR sky130_fd_sc_hd__decap_3
X_7078_ _7234_/CLK _7078_/D _6358_/Y VGND VGND VPWR VPWR _7078_/Q sky130_fd_sc_hd__dfrtp_2
XFILLER_104_32 VGND VGND VPWR VPWR sky130_fd_sc_hd__decap_3
XFILLER_39_370 VGND VGND VPWR VPWR sky130_fd_sc_hd__decap_3
XFILLER_46_318 VGND VGND VPWR VPWR sky130_fd_sc_hd__decap_3
XFILLER_74_638 VGND VGND VPWR VPWR sky130_fd_sc_hd__decap_3
XFILLER_100_297 VGND VGND VPWR VPWR sky130_fd_sc_hd__decap_3
XFILLER_27_543 VGND VGND VPWR VPWR sky130_fd_sc_hd__fill_1
XFILLER_73_148 VGND VGND VPWR VPWR sky130_fd_sc_hd__decap_3
XFILLER_42_513 VGND VGND VPWR VPWR sky130_fd_sc_hd__decap_3
XFILLER_54_362 VGND VGND VPWR VPWR sky130_fd_sc_hd__fill_2
XFILLER_64_58 VGND VGND VPWR VPWR sky130_fd_sc_hd__fill_1
XFILLER_82_660 VGND VGND VPWR VPWR sky130_fd_sc_hd__decap_3
XFILLER_14_215 VGND VGND VPWR VPWR sky130_fd_sc_hd__decap_3
XFILLER_54_395 VGND VGND VPWR VPWR sky130_fd_sc_hd__decap_3
XFILLER_81_181 VGND VGND VPWR VPWR sky130_fd_sc_hd__decap_3
XFILLER_81_192 VGND VGND VPWR VPWR sky130_fd_sc_hd__decap_3
XTAP_TAPCELL_ROW_64_1016 VGND VPWR sky130_fd_sc_hd__tapvpwrvgnd_1
XFILLER_14_248 VGND VGND VPWR VPWR sky130_fd_sc_hd__decap_3
XFILLER_14_259 VGND VGND VPWR VPWR sky130_fd_sc_hd__decap_3
XFILLER_42_557 VGND VGND VPWR VPWR sky130_fd_sc_hd__decap_3
XFILLER_80_24 VGND VGND VPWR VPWR sky130_fd_sc_hd__decap_3
Xfanout30 fanout38/X VGND VGND VPWR VPWR _6535_/A sky130_fd_sc_hd__buf_2
XFILLER_22_270 VGND VGND VPWR VPWR sky130_fd_sc_hd__decap_3
Xfanout41 _6547_/A VGND VGND VPWR VPWR _6610_/A sky130_fd_sc_hd__clkdlybuf4s25_1
Xfanout52 _6686_/A VGND VGND VPWR VPWR _6660_/A sky130_fd_sc_hd__buf_2
Xfanout63 fanout72/X VGND VGND VPWR VPWR _6682_/A sky130_fd_sc_hd__buf_2
XTAP_TAPCELL_ROW_40_736 VGND VPWR sky130_fd_sc_hd__tapvpwrvgnd_1
XFILLER_10_421 VGND VGND VPWR VPWR sky130_fd_sc_hd__fill_1
XFILLER_6_414 VGND VGND VPWR VPWR sky130_fd_sc_hd__decap_3
XFILLER_6_436 VGND VGND VPWR VPWR sky130_fd_sc_hd__decap_3
XTAP_TAPCELL_ROW_20_493 VGND VPWR sky130_fd_sc_hd__tapvpwrvgnd_1
XFILLER_89_44 VGND VGND VPWR VPWR sky130_fd_sc_hd__decap_3
XFILLER_2_642 VGND VGND VPWR VPWR sky130_fd_sc_hd__fill_2
XFILLER_89_77 VGND VGND VPWR VPWR sky130_fd_sc_hd__fill_2
XTAP_TAPCELL_ROW_75_1156 VGND VPWR sky130_fd_sc_hd__tapvpwrvgnd_1
XFILLER_1_152 VGND VGND VPWR VPWR sky130_fd_sc_hd__decap_3
XFILLER_2_675 VGND VGND VPWR VPWR sky130_fd_sc_hd__decap_3
XFILLER_29_9 VGND VGND VPWR VPWR sky130_fd_sc_hd__decap_3
XFILLER_77_432 VGND VGND VPWR VPWR sky130_fd_sc_hd__decap_3
XFILLER_49_178 VGND VGND VPWR VPWR sky130_fd_sc_hd__decap_3
XFILLER_65_638 VGND VGND VPWR VPWR sky130_fd_sc_hd__decap_3
XFILLER_77_498 VGND VGND VPWR VPWR sky130_fd_sc_hd__decap_3
XTAP_TAPCELL_ROW_48_825 VGND VPWR sky130_fd_sc_hd__tapvpwrvgnd_1
XPHY_EDGE_ROW_32_Left_149 VGND VGND VPWR VPWR sky130_fd_sc_hd__decap_3
XFILLER_73_671 VGND VGND VPWR VPWR sky130_fd_sc_hd__fill_1
XFILLER_73_682 VGND VGND VPWR VPWR sky130_fd_sc_hd__fill_2
XTAP_TAPCELL_ROW_86_1285 VGND VPWR sky130_fd_sc_hd__tapvpwrvgnd_1
XTAP_TAPCELL_ROW_28_593 VGND VPWR sky130_fd_sc_hd__tapvpwrvgnd_1
XTAP_TAPCELL_ROW_28_582 VGND VPWR sky130_fd_sc_hd__tapvpwrvgnd_1
XFILLER_54_80 VGND VGND VPWR VPWR sky130_fd_sc_hd__decap_3
XFILLER_54_91 VGND VGND VPWR VPWR sky130_fd_sc_hd__decap_3
XFILLER_20_229 VGND VGND VPWR VPWR sky130_fd_sc_hd__decap_3
XFILLER_60_376 VGND VGND VPWR VPWR sky130_fd_sc_hd__decap_3
X_3730_ _6956_/Q _3882_/A2 _3884_/B1 _6950_/Q _3729_/X VGND VGND VPWR VPWR _3730_/X
+ sky130_fd_sc_hd__a221o_2
XFILLER_13_281 VGND VGND VPWR VPWR sky130_fd_sc_hd__decap_3
X_3661_ _3991_/B _3665_/B VGND VGND VPWR VPWR _3661_/X sky130_fd_sc_hd__and2_4
XFILLER_62_3 VGND VGND VPWR VPWR sky130_fd_sc_hd__decap_3
Xclkload11 _7352_/CLK VGND VGND VPWR VPWR clkload11/X sky130_fd_sc_hd__clkbuf_1
Xclkload22 _7398_/CLK VGND VGND VPWR VPWR clkload22/X sky130_fd_sc_hd__clkbuf_1
Xclkload33 _7403_/CLK VGND VGND VPWR VPWR clkload33/X sky130_fd_sc_hd__clkbuf_8
X_6380_ _6540_/A VGND VGND VPWR VPWR _6380_/Y sky130_fd_sc_hd__inv_2
X_5400_ _5400_/A0 _5011_/X _5429_/S VGND VGND VPWR VPWR _7133_/D sky130_fd_sc_hd__mux2_2
X_3592_ _4292_/B _3620_/C _3591_/Y VGND VGND VPWR VPWR _3592_/X sky130_fd_sc_hd__a21o_2
XPHY_EDGE_ROW_41_Left_158 VGND VGND VPWR VPWR sky130_fd_sc_hd__decap_3
XFILLER_114_301 VGND VGND VPWR VPWR sky130_fd_sc_hd__decap_3
XFILLER_114_312 VGND VGND VPWR VPWR sky130_fd_sc_hd__decap_3
X_5331_ _5331_/A0 _5011_/X _5360_/S VGND VGND VPWR VPWR _7165_/D sky130_fd_sc_hd__mux2_2
XFILLER_114_345 VGND VGND VPWR VPWR sky130_fd_sc_hd__decap_3
X_7001_ _7406_/CLK _7001_/D _6281_/Y VGND VGND VPWR VPWR _7001_/Q sky130_fd_sc_hd__dfrtp_2
X_5262_ _5262_/A0 _4978_/X _5262_/S VGND VGND VPWR VPWR _7199_/D sky130_fd_sc_hd__mux2_2
X_4213_ _7292_/Q _4517_/S _4261_/A2 _7356_/Q _4347_/C1 VGND VGND VPWR VPWR _4213_/X
+ sky130_fd_sc_hd__a221o_2
XFILLER_110_551 VGND VGND VPWR VPWR sky130_fd_sc_hd__decap_3
XFILLER_95_240 VGND VGND VPWR VPWR sky130_fd_sc_hd__decap_3
X_4144_ _7362_/Q _4419_/B1 _4261_/B1 _7170_/Q VGND VGND VPWR VPWR _4144_/X sky130_fd_sc_hd__a22o_2
XFILLER_110_584 VGND VGND VPWR VPWR sky130_fd_sc_hd__decap_3
XFILLER_18_18 VGND VGND VPWR VPWR sky130_fd_sc_hd__decap_3
XFILLER_18_29 VGND VGND VPWR VPWR sky130_fd_sc_hd__decap_3
XFILLER_56_616 VGND VGND VPWR VPWR sky130_fd_sc_hd__decap_3
XFILLER_68_498 VGND VGND VPWR VPWR sky130_fd_sc_hd__decap_3
XFILLER_83_424 VGND VGND VPWR VPWR sky130_fd_sc_hd__decap_3
XFILLER_95_273 VGND VGND VPWR VPWR sky130_fd_sc_hd__decap_3
XPHY_EDGE_ROW_50_Left_167 VGND VGND VPWR VPWR sky130_fd_sc_hd__decap_3
XFILLER_110_595 VGND VGND VPWR VPWR sky130_fd_sc_hd__decap_3
XFILLER_55_148 VGND VGND VPWR VPWR sky130_fd_sc_hd__decap_3
X_4075_ _7211_/Q _3954_/S _4417_/A2 _7307_/Q VGND VGND VPWR VPWR _4075_/X sky130_fd_sc_hd__a22o_2
XFILLER_36_362 VGND VGND VPWR VPWR sky130_fd_sc_hd__fill_2
XFILLER_64_660 VGND VGND VPWR VPWR sky130_fd_sc_hd__decap_3
XFILLER_36_384 VGND VGND VPWR VPWR sky130_fd_sc_hd__decap_3
XFILLER_51_321 VGND VGND VPWR VPWR sky130_fd_sc_hd__fill_1
XFILLER_70_118 VGND VGND VPWR VPWR sky130_fd_sc_hd__decap_3
XFILLER_24_568 VGND VGND VPWR VPWR sky130_fd_sc_hd__decap_3
XFILLER_34_39 VGND VGND VPWR VPWR sky130_fd_sc_hd__fill_2
XFILLER_51_343 VGND VGND VPWR VPWR sky130_fd_sc_hd__decap_3
XFILLER_51_376 VGND VGND VPWR VPWR sky130_fd_sc_hd__decap_3
XFILLER_51_387 VGND VGND VPWR VPWR sky130_fd_sc_hd__decap_3
X_6716_ _7405_/CLK _6716_/D VGND VGND VPWR VPWR _6716_/Q sky130_fd_sc_hd__dfxtp_2
X_4977_ _4977_/A _4977_/B VGND VGND VPWR VPWR _6993_/D sky130_fd_sc_hd__nor2_2
Xclkload5 clkload5/A VGND VGND VPWR VPWR clkload5/X sky130_fd_sc_hd__clkbuf_1
X_3928_ hold985/X _3864_/S _3927_/X VGND VGND VPWR VPWR _7375_/D sky130_fd_sc_hd__o21a_2
XFILLER_109_128 VGND VGND VPWR VPWR sky130_fd_sc_hd__decap_3
XFILLER_50_49 VGND VGND VPWR VPWR sky130_fd_sc_hd__decap_3
X_6647_ _6647_/A VGND VGND VPWR VPWR _6647_/Y sky130_fd_sc_hd__inv_2
X_3859_ _6924_/Q _3926_/A2 _3926_/B1 _6788_/Q _3858_/X VGND VGND VPWR VPWR _3859_/X
+ sky130_fd_sc_hd__a221o_2
X_6578_ _6578_/A VGND VGND VPWR VPWR _6578_/Y sky130_fd_sc_hd__inv_2
XFILLER_3_417 VGND VGND VPWR VPWR sky130_fd_sc_hd__decap_3
XFILLER_105_389 VGND VGND VPWR VPWR sky130_fd_sc_hd__decap_3
XFILLER_115_20 VGND VGND VPWR VPWR sky130_fd_sc_hd__decap_3
XFILLER_59_69 VGND VGND VPWR VPWR sky130_fd_sc_hd__decap_3
XFILLER_115_53 VGND VGND VPWR VPWR sky130_fd_sc_hd__decap_3
XFILLER_115_75 VGND VGND VPWR VPWR sky130_fd_sc_hd__decap_3
XFILLER_47_638 VGND VGND VPWR VPWR sky130_fd_sc_hd__decap_3
XFILLER_59_476 VGND VGND VPWR VPWR sky130_fd_sc_hd__decap_3
XFILLER_74_424 VGND VGND VPWR VPWR sky130_fd_sc_hd__decap_3
XFILLER_86_262 VGND VGND VPWR VPWR sky130_fd_sc_hd__decap_3
XTAP_TAPCELL_ROW_70_1097 VGND VPWR sky130_fd_sc_hd__tapvpwrvgnd_1
XTAP_TAPCELL_ROW_70_1086 VGND VPWR sky130_fd_sc_hd__tapvpwrvgnd_1
XFILLER_46_126 VGND VGND VPWR VPWR sky130_fd_sc_hd__fill_1
XFILLER_75_57 VGND VGND VPWR VPWR sky130_fd_sc_hd__decap_3
XFILLER_86_295 VGND VGND VPWR VPWR sky130_fd_sc_hd__decap_3
XFILLER_15_502 VGND VGND VPWR VPWR sky130_fd_sc_hd__fill_2
XFILLER_46_159 VGND VGND VPWR VPWR sky130_fd_sc_hd__decap_3
XFILLER_55_671 VGND VGND VPWR VPWR sky130_fd_sc_hd__fill_1
XFILLER_62_619 VGND VGND VPWR VPWR sky130_fd_sc_hd__decap_3
XFILLER_74_468 VGND VGND VPWR VPWR sky130_fd_sc_hd__fill_1
XFILLER_55_682 VGND VGND VPWR VPWR sky130_fd_sc_hd__decap_3
XFILLER_91_12 VGND VGND VPWR VPWR sky130_fd_sc_hd__decap_3
XFILLER_54_192 VGND VGND VPWR VPWR sky130_fd_sc_hd__decap_3
XFILLER_70_663 VGND VGND VPWR VPWR sky130_fd_sc_hd__decap_3
XFILLER_30_516 VGND VGND VPWR VPWR sky130_fd_sc_hd__decap_3
XFILLER_42_365 VGND VGND VPWR VPWR sky130_fd_sc_hd__decap_3
XFILLER_42_376 VGND VGND VPWR VPWR sky130_fd_sc_hd__decap_3
XFILLER_91_78 VGND VGND VPWR VPWR sky130_fd_sc_hd__decap_3
XTAP_TAPCELL_ROW_53_883 VGND VPWR sky130_fd_sc_hd__tapvpwrvgnd_1
XTAP_TAPCELL_ROW_25_552 VGND VPWR sky130_fd_sc_hd__tapvpwrvgnd_1
XFILLER_24_94 VGND VGND VPWR VPWR sky130_fd_sc_hd__decap_3
XFILLER_10_262 VGND VGND VPWR VPWR sky130_fd_sc_hd__decap_3
XFILLER_108_150 VGND VGND VPWR VPWR sky130_fd_sc_hd__decap_3
XFILLER_109_662 VGND VGND VPWR VPWR sky130_fd_sc_hd__decap_3
XFILLER_109_673 VGND VGND VPWR VPWR sky130_fd_sc_hd__decap_3
XFILLER_40_60 VGND VGND VPWR VPWR sky130_fd_sc_hd__decap_3
XFILLER_108_183 VGND VGND VPWR VPWR sky130_fd_sc_hd__decap_3
XFILLER_40_93 VGND VGND VPWR VPWR sky130_fd_sc_hd__decap_3
XFILLER_6_299 VGND VGND VPWR VPWR sky130_fd_sc_hd__fill_2
XFILLER_97_505 VGND VGND VPWR VPWR sky130_fd_sc_hd__decap_3
XFILLER_111_337 VGND VGND VPWR VPWR sky130_fd_sc_hd__decap_3
XFILLER_2_472 VGND VGND VPWR VPWR sky130_fd_sc_hd__decap_3
XFILLER_27_6 VGND VGND VPWR VPWR sky130_fd_sc_hd__decap_3
XFILLER_1_32 VGND VGND VPWR VPWR sky130_fd_sc_hd__decap_3
XFILLER_65_402 VGND VGND VPWR VPWR sky130_fd_sc_hd__decap_3
XFILLER_77_251 VGND VGND VPWR VPWR sky130_fd_sc_hd__decap_3
XTAP_TAPCELL_ROW_88_1303 VGND VPWR sky130_fd_sc_hd__tapvpwrvgnd_1
XFILLER_65_457 VGND VGND VPWR VPWR sky130_fd_sc_hd__decap_3
XFILLER_77_295 VGND VGND VPWR VPWR sky130_fd_sc_hd__decap_3
XFILLER_92_210 VGND VGND VPWR VPWR sky130_fd_sc_hd__fill_1
XFILLER_92_221 VGND VGND VPWR VPWR sky130_fd_sc_hd__fill_2
XFILLER_18_351 VGND VGND VPWR VPWR sky130_fd_sc_hd__fill_2
XFILLER_1_87 VGND VGND VPWR VPWR sky130_fd_sc_hd__decap_3
XFILLER_46_660 VGND VGND VPWR VPWR sky130_fd_sc_hd__decap_3
XFILLER_45_181 VGND VGND VPWR VPWR sky130_fd_sc_hd__decap_3
XFILLER_65_90 VGND VGND VPWR VPWR sky130_fd_sc_hd__decap_3
XFILLER_80_427 VGND VGND VPWR VPWR sky130_fd_sc_hd__decap_3
XFILLER_92_298 VGND VGND VPWR VPWR sky130_fd_sc_hd__fill_1
XFILLER_33_332 VGND VGND VPWR VPWR sky130_fd_sc_hd__decap_3
XFILLER_33_343 VGND VGND VPWR VPWR sky130_fd_sc_hd__decap_3
XFILLER_61_641 VGND VGND VPWR VPWR sky130_fd_sc_hd__decap_3
X_4831_ _4969_/B _4827_/X _4828_/X _4830_/X VGND VGND VPWR VPWR _5657_/A sky130_fd_sc_hd__a211o_2
XFILLER_21_505 VGND VGND VPWR VPWR sky130_fd_sc_hd__fill_2
XFILLER_60_151 VGND VGND VPWR VPWR sky130_fd_sc_hd__fill_1
XFILLER_60_162 VGND VGND VPWR VPWR sky130_fd_sc_hd__decap_3
XFILLER_61_685 VGND VGND VPWR VPWR sky130_fd_sc_hd__decap_3
X_4762_ _4762_/A _4762_/B VGND VGND VPWR VPWR _4762_/Y sky130_fd_sc_hd__nor2_2
X_6501_ _6599_/A VGND VGND VPWR VPWR _6501_/Y sky130_fd_sc_hd__inv_2
X_4693_ _7007_/Q _4750_/B VGND VGND VPWR VPWR _4728_/A sky130_fd_sc_hd__nand2_2
X_3713_ _3733_/C VGND VGND VPWR VPWR _3746_/C sky130_fd_sc_hd__inv_4
XTAP_TAPCELL_ROW_99_1443 VGND VPWR sky130_fd_sc_hd__tapvpwrvgnd_1
X_6432_ _6637_/A VGND VGND VPWR VPWR _6432_/Y sky130_fd_sc_hd__inv_2
X_3644_ _3629_/Y _3642_/X _4799_/A VGND VGND VPWR VPWR _4664_/B sky130_fd_sc_hd__o21a_2
XFILLER_115_632 VGND VGND VPWR VPWR sky130_fd_sc_hd__decap_3
X_6363_ _6366_/A VGND VGND VPWR VPWR _6363_/Y sky130_fd_sc_hd__inv_2
X_3575_ _7156_/Q _4339_/B1 _4303_/B1 _7124_/Q _3574_/X VGND VGND VPWR VPWR _3575_/X
+ sky130_fd_sc_hd__a221o_2
XFILLER_0_409 VGND VGND VPWR VPWR sky130_fd_sc_hd__decap_3
XFILLER_114_153 VGND VGND VPWR VPWR sky130_fd_sc_hd__decap_3
XFILLER_115_665 VGND VGND VPWR VPWR sky130_fd_sc_hd__decap_3
XFILLER_115_676 VGND VGND VPWR VPWR sky130_fd_sc_hd__decap_3
X_6294_ _6532_/A VGND VGND VPWR VPWR _6294_/Y sky130_fd_sc_hd__inv_2
XFILLER_102_304 VGND VGND VPWR VPWR sky130_fd_sc_hd__decap_3
XFILLER_102_315 VGND VGND VPWR VPWR sky130_fd_sc_hd__decap_3
XFILLER_114_186 VGND VGND VPWR VPWR sky130_fd_sc_hd__decap_3
XFILLER_88_527 VGND VGND VPWR VPWR sky130_fd_sc_hd__decap_3
X_5245_ _5245_/A0 _4836_/X _5245_/S VGND VGND VPWR VPWR _7207_/D sky130_fd_sc_hd__mux2_2
XFILLER_102_359 VGND VGND VPWR VPWR sky130_fd_sc_hd__decap_3
XFILLER_114_197 VGND VGND VPWR VPWR sky130_fd_sc_hd__decap_3
XFILLER_28_104 VGND VGND VPWR VPWR sky130_fd_sc_hd__fill_1
XFILLER_28_137 VGND VGND VPWR VPWR sky130_fd_sc_hd__decap_3
XFILLER_68_295 VGND VGND VPWR VPWR sky130_fd_sc_hd__decap_3
XFILLER_83_221 VGND VGND VPWR VPWR sky130_fd_sc_hd__decap_3
XFILLER_83_232 VGND VGND VPWR VPWR sky130_fd_sc_hd__decap_3
X_4058_ _7244_/Q _4430_/A2 _4430_/B1 _7180_/Q _4057_/X VGND VGND VPWR VPWR _4058_/X
+ sky130_fd_sc_hd__a221o_2
XTAP_TAPCELL_ROW_108_1550 VGND VPWR sky130_fd_sc_hd__tapvpwrvgnd_1
XFILLER_37_682 VGND VGND VPWR VPWR sky130_fd_sc_hd__decap_3
XFILLER_71_449 VGND VGND VPWR VPWR sky130_fd_sc_hd__fill_1
XFILLER_101_11 VGND VGND VPWR VPWR sky130_fd_sc_hd__decap_3
XFILLER_36_181 VGND VGND VPWR VPWR sky130_fd_sc_hd__decap_3
XFILLER_52_663 VGND VGND VPWR VPWR sky130_fd_sc_hd__decap_3
XFILLER_24_365 VGND VGND VPWR VPWR sky130_fd_sc_hd__fill_2
XFILLER_24_376 VGND VGND VPWR VPWR sky130_fd_sc_hd__decap_3
XFILLER_51_151 VGND VGND VPWR VPWR sky130_fd_sc_hd__fill_2
XFILLER_61_15 VGND VGND VPWR VPWR sky130_fd_sc_hd__decap_3
XFILLER_101_77 VGND VGND VPWR VPWR sky130_fd_sc_hd__decap_3
XTAP_TAPCELL_ROW_22_511 VGND VPWR sky130_fd_sc_hd__tapvpwrvgnd_1
XTAP_TAPCELL_ROW_50_853 VGND VPWR sky130_fd_sc_hd__tapvpwrvgnd_1
XFILLER_106_621 VGND VGND VPWR VPWR sky130_fd_sc_hd__decap_3
XFILLER_3_225 VGND VGND VPWR VPWR sky130_fd_sc_hd__decap_3
XFILLER_106_654 VGND VGND VPWR VPWR sky130_fd_sc_hd__decap_3
XFILLER_10_41 VGND VGND VPWR VPWR sky130_fd_sc_hd__decap_3
XTAP_TAPCELL_ROW_72_1115 VGND VPWR sky130_fd_sc_hd__tapvpwrvgnd_1
XFILLER_106_687 VGND VGND VPWR VPWR sky130_fd_sc_hd__decap_3
XFILLER_10_74 VGND VGND VPWR VPWR sky130_fd_sc_hd__decap_3
XFILLER_10_85 VGND VGND VPWR VPWR sky130_fd_sc_hd__decap_3
XFILLER_19_104 VGND VGND VPWR VPWR sky130_fd_sc_hd__decap_3
XFILLER_47_402 VGND VGND VPWR VPWR sky130_fd_sc_hd__decap_3
XFILLER_59_262 VGND VGND VPWR VPWR sky130_fd_sc_hd__decap_3
XTAP_TAPCELL_ROW_58_942 VGND VPWR sky130_fd_sc_hd__tapvpwrvgnd_1
XFILLER_47_468 VGND VGND VPWR VPWR sky130_fd_sc_hd__fill_2
XFILLER_62_405 VGND VGND VPWR VPWR sky130_fd_sc_hd__decap_3
XFILLER_74_265 VGND VGND VPWR VPWR sky130_fd_sc_hd__decap_3
XTAP_TAPCELL_ROW_58_953 VGND VPWR sky130_fd_sc_hd__tapvpwrvgnd_1
XFILLER_62_438 VGND VGND VPWR VPWR sky130_fd_sc_hd__decap_3
XTAP_TAPCELL_ROW_2_280 VGND VPWR sky130_fd_sc_hd__tapvpwrvgnd_1
XFILLER_15_332 VGND VGND VPWR VPWR sky130_fd_sc_hd__decap_3
XFILLER_43_663 VGND VGND VPWR VPWR sky130_fd_sc_hd__decap_3
XTAP_TAPCELL_ROW_83_1244 VGND VPWR sky130_fd_sc_hd__tapvpwrvgnd_1
XPHY_EDGE_ROW_106_Left_223 VGND VGND VPWR VPWR sky130_fd_sc_hd__decap_3
XFILLER_35_71 VGND VGND VPWR VPWR sky130_fd_sc_hd__decap_3
XFILLER_35_82 VGND VGND VPWR VPWR sky130_fd_sc_hd__decap_3
XFILLER_43_685 VGND VGND VPWR VPWR sky130_fd_sc_hd__decap_3
XFILLER_70_471 VGND VGND VPWR VPWR sky130_fd_sc_hd__decap_3
XFILLER_30_368 VGND VGND VPWR VPWR sky130_fd_sc_hd__decap_3
XFILLER_11_571 VGND VGND VPWR VPWR sky130_fd_sc_hd__fill_1
XFILLER_51_81 VGND VGND VPWR VPWR sky130_fd_sc_hd__decap_3
XFILLER_109_492 VGND VGND VPWR VPWR sky130_fd_sc_hd__decap_3
X_3360_ _3365_/A _3362_/A _3371_/A VGND VGND VPWR VPWR _3386_/B sky130_fd_sc_hd__mux2_2
XTAP_TAPCELL_ROW_94_1384 VGND VPWR sky130_fd_sc_hd__tapvpwrvgnd_1
XPHY_EDGE_ROW_115_Left_232 VGND VGND VPWR VPWR sky130_fd_sc_hd__decap_3
XFILLER_112_613 VGND VGND VPWR VPWR sky130_fd_sc_hd__decap_3
XFILLER_97_302 VGND VGND VPWR VPWR sky130_fd_sc_hd__decap_3
XFILLER_111_134 VGND VGND VPWR VPWR sky130_fd_sc_hd__decap_3
XFILLER_112_657 VGND VGND VPWR VPWR sky130_fd_sc_hd__decap_3
XFILLER_97_335 VGND VGND VPWR VPWR sky130_fd_sc_hd__fill_1
X_5030_ _6989_/Q _5044_/A VGND VGND VPWR VPWR _6989_/D sky130_fd_sc_hd__xor2_2
XFILLER_111_167 VGND VGND VPWR VPWR sky130_fd_sc_hd__fill_1
XFILLER_111_178 VGND VGND VPWR VPWR sky130_fd_sc_hd__decap_3
XFILLER_25_3 VGND VGND VPWR VPWR sky130_fd_sc_hd__decap_3
Xhold1209 _7301_/Q VGND VGND VPWR VPWR _4559_/A sky130_fd_sc_hd__dlygate4sd3_1
XFILLER_26_619 VGND VGND VPWR VPWR sky130_fd_sc_hd__decap_3
XFILLER_53_405 VGND VGND VPWR VPWR sky130_fd_sc_hd__decap_3
X_6981_ _7266_/CLK _6981_/D _6261_/Y VGND VGND VPWR VPWR _6981_/Q sky130_fd_sc_hd__dfrtp_2
XFILLER_93_585 VGND VGND VPWR VPWR sky130_fd_sc_hd__decap_3
XTAP_TAPCELL_ROW_0_239 VGND VPWR sky130_fd_sc_hd__tapvpwrvgnd_1
XFILLER_18_192 VGND VGND VPWR VPWR sky130_fd_sc_hd__decap_3
XFILLER_46_490 VGND VGND VPWR VPWR sky130_fd_sc_hd__decap_3
XFILLER_53_449 VGND VGND VPWR VPWR sky130_fd_sc_hd__decap_3
Xclkbuf_leaf_45_clk clkbuf_3_0__f_clk/X VGND VGND VPWR VPWR clkload6/A sky130_fd_sc_hd__clkbuf_16
XFILLER_21_302 VGND VGND VPWR VPWR sky130_fd_sc_hd__decap_3
XFILLER_33_140 VGND VGND VPWR VPWR sky130_fd_sc_hd__decap_3
XFILLER_34_663 VGND VGND VPWR VPWR sky130_fd_sc_hd__decap_3
XFILLER_21_346 VGND VGND VPWR VPWR sky130_fd_sc_hd__decap_3
X_4814_ _4814_/A _4814_/B VGND VGND VPWR VPWR _4814_/Y sky130_fd_sc_hd__nor2_2
X_4745_ _4745_/A VGND VGND VPWR VPWR _4745_/Y sky130_fd_sc_hd__inv_2
XTAP_TAPCELL_ROW_103_1491 VGND VPWR sky130_fd_sc_hd__tapvpwrvgnd_1
XFILLER_31_18 VGND VGND VPWR VPWR sky130_fd_sc_hd__decap_3
X_4676_ _5648_/A _5067_/B _6985_/Q _6986_/Q _6987_/Q VGND VGND VPWR VPWR _5045_/B
+ sky130_fd_sc_hd__o2111a_2
X_7395_ _7402_/CLK _7395_/D _6675_/Y VGND VGND VPWR VPWR _7395_/Q sky130_fd_sc_hd__dfrtp_2
X_6415_ _6548_/A VGND VGND VPWR VPWR _6415_/Y sky130_fd_sc_hd__inv_2
X_3627_ _3746_/A _3746_/B _3733_/C VGND VGND VPWR VPWR _5660_/A sky130_fd_sc_hd__and3_2
X_6346_ _6540_/A VGND VGND VPWR VPWR _6346_/Y sky130_fd_sc_hd__inv_2
X_3558_ _7061_/Q _3577_/B VGND VGND VPWR VPWR _3558_/X sky130_fd_sc_hd__or2_2
XFILLER_0_228 VGND VGND VPWR VPWR sky130_fd_sc_hd__decap_3
XFILLER_103_635 VGND VGND VPWR VPWR sky130_fd_sc_hd__decap_3
XFILLER_103_668 VGND VGND VPWR VPWR sky130_fd_sc_hd__decap_3
XFILLER_88_335 VGND VGND VPWR VPWR sky130_fd_sc_hd__decap_3
XFILLER_88_368 VGND VGND VPWR VPWR sky130_fd_sc_hd__decap_3
X_6277_ _6280_/A VGND VGND VPWR VPWR _6277_/Y sky130_fd_sc_hd__inv_2
X_3489_ _7311_/Q _3989_/S _4332_/B1 _7343_/Q _3488_/X VGND VGND VPWR VPWR _3489_/X
+ sky130_fd_sc_hd__a221o_2
XFILLER_102_178 VGND VGND VPWR VPWR sky130_fd_sc_hd__decap_3
XFILLER_103_679 VGND VGND VPWR VPWR sky130_fd_sc_hd__decap_3
X_5228_ _5238_/B VGND VGND VPWR VPWR _5229_/B sky130_fd_sc_hd__inv_2
XFILLER_29_446 VGND VGND VPWR VPWR sky130_fd_sc_hd__fill_2
XFILLER_56_15 VGND VGND VPWR VPWR sky130_fd_sc_hd__decap_3
XFILLER_56_221 VGND VGND VPWR VPWR sky130_fd_sc_hd__decap_3
X_5159_ _5159_/A0 _4470_/X _5159_/S VGND VGND VPWR VPWR _7247_/D sky130_fd_sc_hd__mux2_2
XFILLER_44_405 VGND VGND VPWR VPWR sky130_fd_sc_hd__decap_3
XFILLER_56_265 VGND VGND VPWR VPWR sky130_fd_sc_hd__decap_3
XFILLER_56_48 VGND VGND VPWR VPWR sky130_fd_sc_hd__decap_3
XFILLER_112_32 VGND VGND VPWR VPWR sky130_fd_sc_hd__decap_3
XFILLER_16_107 VGND VGND VPWR VPWR sky130_fd_sc_hd__decap_3
XTAP_TAPCELL_ROW_55_912 VGND VPWR sky130_fd_sc_hd__tapvpwrvgnd_1
XFILLER_112_65 VGND VGND VPWR VPWR sky130_fd_sc_hd__decap_3
XFILLER_25_641 VGND VGND VPWR VPWR sky130_fd_sc_hd__decap_3
Xclkbuf_leaf_36_clk clkbuf_leaf_1_clk/A VGND VGND VPWR VPWR clkload9/A sky130_fd_sc_hd__clkbuf_16
XFILLER_24_162 VGND VGND VPWR VPWR sky130_fd_sc_hd__fill_2
XFILLER_71_268 VGND VGND VPWR VPWR sky130_fd_sc_hd__decap_3
XFILLER_72_58 VGND VGND VPWR VPWR sky130_fd_sc_hd__decap_3
XFILLER_12_346 VGND VGND VPWR VPWR sky130_fd_sc_hd__decap_3
XFILLER_12_368 VGND VGND VPWR VPWR sky130_fd_sc_hd__decap_3
XFILLER_40_688 VGND VGND VPWR VPWR sky130_fd_sc_hd__decap_3
XFILLER_21_73 VGND VGND VPWR VPWR sky130_fd_sc_hd__decap_3
XFILLER_4_512 VGND VGND VPWR VPWR sky130_fd_sc_hd__fill_1
XFILLER_106_451 VGND VGND VPWR VPWR sky130_fd_sc_hd__decap_3
XFILLER_79_324 VGND VGND VPWR VPWR sky130_fd_sc_hd__decap_3
XFILLER_97_33 VGND VGND VPWR VPWR sky130_fd_sc_hd__decap_3
XFILLER_79_346 VGND VGND VPWR VPWR sky130_fd_sc_hd__decap_3
XFILLER_97_88 VGND VGND VPWR VPWR sky130_fd_sc_hd__fill_2
XFILLER_67_508 VGND VGND VPWR VPWR sky130_fd_sc_hd__decap_3
XFILLER_102_690 VGND VGND VPWR VPWR sky130_fd_sc_hd__fill_2
XFILLER_11_9 VGND VGND VPWR VPWR sky130_fd_sc_hd__decap_3
XFILLER_94_338 VGND VGND VPWR VPWR sky130_fd_sc_hd__fill_2
XFILLER_35_405 VGND VGND VPWR VPWR sky130_fd_sc_hd__decap_3
XFILLER_47_243 VGND VGND VPWR VPWR sky130_fd_sc_hd__fill_2
XFILLER_75_541 VGND VGND VPWR VPWR sky130_fd_sc_hd__decap_3
XFILLER_35_427 VGND VGND VPWR VPWR sky130_fd_sc_hd__fill_1
XFILLER_47_276 VGND VGND VPWR VPWR sky130_fd_sc_hd__decap_3
XFILLER_75_596 VGND VGND VPWR VPWR sky130_fd_sc_hd__fill_2
XFILLER_90_533 VGND VGND VPWR VPWR sky130_fd_sc_hd__decap_3
XFILLER_35_449 VGND VGND VPWR VPWR sky130_fd_sc_hd__decap_3
Xclkbuf_leaf_27_clk clkload0/A VGND VGND VPWR VPWR _6976_/CLK sky130_fd_sc_hd__clkbuf_16
XFILLER_15_151 VGND VGND VPWR VPWR sky130_fd_sc_hd__decap_3
XFILLER_31_600 VGND VGND VPWR VPWR sky130_fd_sc_hd__decap_3
XFILLER_62_268 VGND VGND VPWR VPWR sky130_fd_sc_hd__decap_3
XFILLER_15_195 VGND VGND VPWR VPWR sky130_fd_sc_hd__decap_3
XFILLER_94_6 VGND VGND VPWR VPWR sky130_fd_sc_hd__decap_3
XFILLER_62_80 VGND VGND VPWR VPWR sky130_fd_sc_hd__decap_3
XFILLER_30_165 VGND VGND VPWR VPWR sky130_fd_sc_hd__decap_3
XFILLER_7_42 VGND VGND VPWR VPWR sky130_fd_sc_hd__decap_3
X_4530_ _4530_/A0 _4597_/A0 _4534_/S VGND VGND VPWR VPWR _7314_/D sky130_fd_sc_hd__mux2_2
XTAP_TAPCELL_ROW_96_1402 VGND VPWR sky130_fd_sc_hd__tapvpwrvgnd_1
XFILLER_116_237 VGND VGND VPWR VPWR sky130_fd_sc_hd__decap_3
XFILLER_7_361 VGND VGND VPWR VPWR sky130_fd_sc_hd__decap_3
XFILLER_7_75 VGND VGND VPWR VPWR sky130_fd_sc_hd__decap_3
XFILLER_116_259 VGND VGND VPWR VPWR sky130_fd_sc_hd__decap_3
X_7180_ _7310_/CLK _7180_/D _6460_/Y VGND VGND VPWR VPWR _7180_/Q sky130_fd_sc_hd__dfrtp_2
X_3412_ _7187_/Q _3987_/S _4332_/B1 _7379_/Q VGND VGND VPWR VPWR _3412_/X sky130_fd_sc_hd__a22o_2
X_4392_ _7369_/Q _4435_/B1 _4434_/B1 _7145_/Q _4391_/X VGND VGND VPWR VPWR _4392_/X
+ sky130_fd_sc_hd__a221o_2
XFILLER_98_633 VGND VGND VPWR VPWR sky130_fd_sc_hd__decap_3
XFILLER_112_421 VGND VGND VPWR VPWR sky130_fd_sc_hd__decap_3
XFILLER_97_132 VGND VGND VPWR VPWR sky130_fd_sc_hd__fill_1
XTAP_TAPCELL_ROW_5_309 VGND VPWR sky130_fd_sc_hd__tapvpwrvgnd_1
XFILLER_98_666 VGND VGND VPWR VPWR sky130_fd_sc_hd__decap_3
XFILLER_85_305 VGND VGND VPWR VPWR sky130_fd_sc_hd__decap_3
XFILLER_97_154 VGND VGND VPWR VPWR sky130_fd_sc_hd__decap_3
Xhold1006 _7209_/Q VGND VGND VPWR VPWR _5241_/A0 sky130_fd_sc_hd__dlygate4sd3_1
XFILLER_100_638 VGND VGND VPWR VPWR sky130_fd_sc_hd__decap_3
XFILLER_112_498 VGND VGND VPWR VPWR sky130_fd_sc_hd__decap_3
Xhold1017 _7205_/Q VGND VGND VPWR VPWR _5249_/A0 sky130_fd_sc_hd__dlygate4sd3_1
Xhold1028 _7259_/Q VGND VGND VPWR VPWR _5041_/A0 sky130_fd_sc_hd__dlygate4sd3_1
Xhold1039 _7038_/Q VGND VGND VPWR VPWR _5581_/A0 sky130_fd_sc_hd__dlygate4sd3_1
XFILLER_26_18 VGND VGND VPWR VPWR sky130_fd_sc_hd__decap_3
XFILLER_26_405 VGND VGND VPWR VPWR sky130_fd_sc_hd__decap_3
XFILLER_26_438 VGND VGND VPWR VPWR sky130_fd_sc_hd__fill_2
XFILLER_38_265 VGND VGND VPWR VPWR sky130_fd_sc_hd__decap_3
XFILLER_38_287 VGND VGND VPWR VPWR sky130_fd_sc_hd__decap_3
XFILLER_53_213 VGND VGND VPWR VPWR sky130_fd_sc_hd__decap_3
XFILLER_66_585 VGND VGND VPWR VPWR sky130_fd_sc_hd__decap_3
XFILLER_81_511 VGND VGND VPWR VPWR sky130_fd_sc_hd__fill_1
XFILLER_53_246 VGND VGND VPWR VPWR sky130_fd_sc_hd__decap_3
Xclkbuf_leaf_18_clk clkbuf_3_6__f_clk/X VGND VGND VPWR VPWR _7005_/CLK sky130_fd_sc_hd__clkbuf_16
X_6964_ _6972_/CLK _6964_/D VGND VGND VPWR VPWR _6964_/Q sky130_fd_sc_hd__dfxtp_2
XPHY_EDGE_ROW_5_Right_5 VGND VGND VPWR VPWR sky130_fd_sc_hd__decap_3
XFILLER_53_279 VGND VGND VPWR VPWR sky130_fd_sc_hd__fill_1
X_6895_ _7005_/CLK _6895_/D VGND VGND VPWR VPWR _6895_/Q sky130_fd_sc_hd__dfxtp_2
XFILLER_21_165 VGND VGND VPWR VPWR sky130_fd_sc_hd__decap_3
XFILLER_21_187 VGND VGND VPWR VPWR sky130_fd_sc_hd__fill_2
XFILLER_22_688 VGND VGND VPWR VPWR sky130_fd_sc_hd__decap_3
XTAP_TAPCELL_ROW_60_970 VGND VPWR sky130_fd_sc_hd__tapvpwrvgnd_1
X_4728_ _4728_/A _4728_/B VGND VGND VPWR VPWR _4729_/B sky130_fd_sc_hd__nand2_2
X_4659_ _4814_/A _4457_/X _4658_/Y _4852_/A _4040_/Y VGND VGND VPWR VPWR _4659_/X
+ sky130_fd_sc_hd__o2111a_2
XTAP_TAPCELL_ROW_116_1660 VGND VPWR sky130_fd_sc_hd__tapvpwrvgnd_1
XFILLER_107_32 VGND VGND VPWR VPWR sky130_fd_sc_hd__decap_3
XFILLER_89_611 VGND VGND VPWR VPWR sky130_fd_sc_hd__decap_3
X_7378_ clkload9/A _7378_/D _6658_/Y VGND VGND VPWR VPWR _7378_/Q sky130_fd_sc_hd__dfrtp_2
Xhold840 _6806_/Q VGND VGND VPWR VPWR _6806_/D sky130_fd_sc_hd__dlygate4sd3_1
Xhold851 _7098_/Q VGND VGND VPWR VPWR _7098_/D sky130_fd_sc_hd__dlygate4sd3_1
Xhold862 _7082_/Q VGND VGND VPWR VPWR _7082_/D sky130_fd_sc_hd__dlygate4sd3_1
Xhold873 _7092_/Q VGND VGND VPWR VPWR _7092_/D sky130_fd_sc_hd__dlygate4sd3_1
Xmax_cap570 _3378_/Y VGND VGND VPWR VPWR _4420_/B1 sky130_fd_sc_hd__buf_2
XFILLER_115_270 VGND VGND VPWR VPWR sky130_fd_sc_hd__decap_3
XFILLER_115_281 VGND VGND VPWR VPWR sky130_fd_sc_hd__decap_3
XFILLER_88_132 VGND VGND VPWR VPWR sky130_fd_sc_hd__decap_3
XFILLER_89_644 VGND VGND VPWR VPWR sky130_fd_sc_hd__decap_3
Xhold884 _7071_/Q VGND VGND VPWR VPWR _7071_/D sky130_fd_sc_hd__dlygate4sd3_1
Xhold895 _7083_/Q VGND VGND VPWR VPWR _7083_/D sky130_fd_sc_hd__dlygate4sd3_1
X_6329_ _6616_/A VGND VGND VPWR VPWR _6329_/Y sky130_fd_sc_hd__inv_2
XFILLER_107_87 VGND VGND VPWR VPWR sky130_fd_sc_hd__decap_3
XFILLER_67_36 VGND VGND VPWR VPWR sky130_fd_sc_hd__decap_3
XFILLER_89_688 VGND VGND VPWR VPWR sky130_fd_sc_hd__decap_3
XFILLER_103_498 VGND VGND VPWR VPWR sky130_fd_sc_hd__decap_3
XFILLER_29_221 VGND VGND VPWR VPWR sky130_fd_sc_hd__decap_3
XFILLER_76_327 VGND VGND VPWR VPWR sky130_fd_sc_hd__decap_3
XFILLER_88_187 VGND VGND VPWR VPWR sky130_fd_sc_hd__decap_3
XFILLER_91_308 VGND VGND VPWR VPWR sky130_fd_sc_hd__decap_3
XFILLER_29_276 VGND VGND VPWR VPWR sky130_fd_sc_hd__decap_3
XFILLER_44_213 VGND VGND VPWR VPWR sky130_fd_sc_hd__decap_3
XFILLER_57_585 VGND VGND VPWR VPWR sky130_fd_sc_hd__decap_3
XFILLER_84_371 VGND VGND VPWR VPWR sky130_fd_sc_hd__decap_3
XFILLER_17_449 VGND VGND VPWR VPWR sky130_fd_sc_hd__fill_2
XFILLER_44_246 VGND VGND VPWR VPWR sky130_fd_sc_hd__decap_3
XFILLER_83_57 VGND VGND VPWR VPWR sky130_fd_sc_hd__decap_3
XTAP_TAPCELL_ROW_67_1058 VGND VPWR sky130_fd_sc_hd__tapvpwrvgnd_1
XFILLER_16_62 VGND VGND VPWR VPWR sky130_fd_sc_hd__decap_3
XFILLER_32_419 VGND VGND VPWR VPWR sky130_fd_sc_hd__fill_1
XFILLER_12_110 VGND VGND VPWR VPWR sky130_fd_sc_hd__decap_3
XFILLER_13_644 VGND VGND VPWR VPWR sky130_fd_sc_hd__decap_3
XTAP_TAPCELL_ROW_80_1214 VGND VPWR sky130_fd_sc_hd__tapvpwrvgnd_1
XFILLER_40_430 VGND VGND VPWR VPWR sky130_fd_sc_hd__fill_1
XFILLER_40_441 VGND VGND VPWR VPWR sky130_fd_sc_hd__fill_1
XFILLER_40_452 VGND VGND VPWR VPWR sky130_fd_sc_hd__fill_1
XFILLER_8_103 VGND VGND VPWR VPWR sky130_fd_sc_hd__decap_3
XTAP_TAPCELL_ROW_30_609 VGND VPWR sky130_fd_sc_hd__tapvpwrvgnd_1
XFILLER_9_615 VGND VGND VPWR VPWR sky130_fd_sc_hd__fill_1
XFILLER_8_136 VGND VGND VPWR VPWR sky130_fd_sc_hd__decap_3
XFILLER_8_158 VGND VGND VPWR VPWR sky130_fd_sc_hd__fill_1
XTAP_TAPCELL_ROW_10_377 VGND VPWR sky130_fd_sc_hd__tapvpwrvgnd_1
XTAP_TAPCELL_ROW_10_366 VGND VPWR sky130_fd_sc_hd__tapvpwrvgnd_1
XFILLER_59_9 VGND VGND VPWR VPWR sky130_fd_sc_hd__decap_3
XTAP_TAPCELL_ROW_78_1187 VGND VPWR sky130_fd_sc_hd__tapvpwrvgnd_1
XFILLER_106_292 VGND VGND VPWR VPWR sky130_fd_sc_hd__decap_3
XFILLER_4_397 VGND VGND VPWR VPWR sky130_fd_sc_hd__decap_3
XFILLER_79_110 VGND VGND VPWR VPWR sky130_fd_sc_hd__fill_2
XTAP_TAPCELL_ROW_91_1343 VGND VPWR sky130_fd_sc_hd__tapvpwrvgnd_1
XFILLER_79_143 VGND VGND VPWR VPWR sky130_fd_sc_hd__fill_2
XFILLER_79_165 VGND VGND VPWR VPWR sky130_fd_sc_hd__decap_3
XFILLER_95_614 VGND VGND VPWR VPWR sky130_fd_sc_hd__fill_2
XFILLER_0_592 VGND VGND VPWR VPWR sky130_fd_sc_hd__decap_3
XFILLER_94_135 VGND VGND VPWR VPWR sky130_fd_sc_hd__decap_3
XFILLER_95_647 VGND VGND VPWR VPWR sky130_fd_sc_hd__decap_3
XFILLER_57_80 VGND VGND VPWR VPWR sky130_fd_sc_hd__decap_3
XTAP_TAPCELL_ROW_38_709 VGND VPWR sky130_fd_sc_hd__tapvpwrvgnd_1
XFILLER_35_202 VGND VGND VPWR VPWR sky130_fd_sc_hd__fill_2
XFILLER_94_179 VGND VGND VPWR VPWR sky130_fd_sc_hd__decap_3
XFILLER_63_533 VGND VGND VPWR VPWR sky130_fd_sc_hd__decap_3
XFILLER_75_393 VGND VGND VPWR VPWR sky130_fd_sc_hd__decap_3
XTAP_TAPCELL_ROW_18_466 VGND VPWR sky130_fd_sc_hd__tapvpwrvgnd_1
XFILLER_50_216 VGND VGND VPWR VPWR sky130_fd_sc_hd__decap_3
XFILLER_73_90 VGND VGND VPWR VPWR sky130_fd_sc_hd__decap_3
XFILLER_31_441 VGND VGND VPWR VPWR sky130_fd_sc_hd__fill_1
XFILLER_31_452 VGND VGND VPWR VPWR sky130_fd_sc_hd__decap_3
XFILLER_43_290 VGND VGND VPWR VPWR sky130_fd_sc_hd__decap_3
XFILLER_92_3 VGND VGND VPWR VPWR sky130_fd_sc_hd__decap_3
X_6680_ _6684_/A VGND VGND VPWR VPWR _6680_/Y sky130_fd_sc_hd__inv_2
X_3892_ _6771_/Q _3892_/A2 _3892_/B1 _6765_/Q VGND VGND VPWR VPWR _3892_/X sky130_fd_sc_hd__a22o_2
XFILLER_31_474 VGND VGND VPWR VPWR sky130_fd_sc_hd__decap_3
XTAP_TAPCELL_ROW_100_1450 VGND VPWR sky130_fd_sc_hd__tapvpwrvgnd_1
X_7301_ _7368_/CLK _7301_/D _6581_/Y VGND VGND VPWR VPWR _7301_/Q sky130_fd_sc_hd__dfrtp_2
X_4513_ _4513_/A0 _7291_/Q _4528_/B VGND VGND VPWR VPWR _7323_/D sky130_fd_sc_hd__mux2_2
X_7232_ _7364_/CLK _7232_/D _6512_/Y VGND VGND VPWR VPWR _7232_/Q sky130_fd_sc_hd__dfrtp_2
Xclkbuf_leaf_7_clk clkbuf_leaf_9_clk/A VGND VGND VPWR VPWR _7368_/CLK sky130_fd_sc_hd__clkbuf_16
X_4444_ _4396_/A _4444_/B VGND VGND VPWR VPWR _4444_/X sky130_fd_sc_hd__and2b_2
X_7163_ _7312_/CLK _7163_/D _6443_/Y VGND VGND VPWR VPWR _7163_/Q sky130_fd_sc_hd__dfrtp_2
X_4375_ _5003_/A _4374_/X _4988_/A VGND VGND VPWR VPWR _4375_/X sky130_fd_sc_hd__o21ba_2
XFILLER_98_441 VGND VGND VPWR VPWR sky130_fd_sc_hd__decap_3
XFILLER_112_251 VGND VGND VPWR VPWR sky130_fd_sc_hd__fill_1
XFILLER_58_305 VGND VGND VPWR VPWR sky130_fd_sc_hd__decap_3
XFILLER_86_603 VGND VGND VPWR VPWR sky130_fd_sc_hd__decap_3
X_7094_ _7312_/CLK _7094_/D _6374_/Y VGND VGND VPWR VPWR _7094_/Q sky130_fd_sc_hd__dfrtp_2
X_3326_ _3326_/A _3326_/B VGND VGND VPWR VPWR _5238_/B sky130_fd_sc_hd__nor2_2
XFILLER_58_327 VGND VGND VPWR VPWR sky130_fd_sc_hd__decap_3
XFILLER_85_113 VGND VGND VPWR VPWR sky130_fd_sc_hd__decap_3
XFILLER_86_636 VGND VGND VPWR VPWR sky130_fd_sc_hd__decap_3
XFILLER_37_39 VGND VGND VPWR VPWR sky130_fd_sc_hd__decap_3
XFILLER_85_157 VGND VGND VPWR VPWR sky130_fd_sc_hd__fill_2
XFILLER_86_669 VGND VGND VPWR VPWR sky130_fd_sc_hd__decap_3
XFILLER_66_371 VGND VGND VPWR VPWR sky130_fd_sc_hd__fill_1
XFILLER_26_224 VGND VGND VPWR VPWR sky130_fd_sc_hd__fill_1
XFILLER_26_246 VGND VGND VPWR VPWR sky130_fd_sc_hd__decap_3
XFILLER_81_341 VGND VGND VPWR VPWR sky130_fd_sc_hd__decap_3
XFILLER_14_419 VGND VGND VPWR VPWR sky130_fd_sc_hd__fill_1
XFILLER_53_27 VGND VGND VPWR VPWR sky130_fd_sc_hd__decap_3
XFILLER_54_577 VGND VGND VPWR VPWR sky130_fd_sc_hd__decap_3
X_6947_ _6965_/CLK _6947_/D VGND VGND VPWR VPWR _6947_/Q sky130_fd_sc_hd__dfxtp_2
XFILLER_41_249 VGND VGND VPWR VPWR sky130_fd_sc_hd__decap_3
X_6878_ _7386_/CLK _6878_/D VGND VGND VPWR VPWR _6878_/Q sky130_fd_sc_hd__dfxtp_2
XFILLER_5_128 VGND VGND VPWR VPWR sky130_fd_sc_hd__decap_3
XTAP_TAPCELL_ROW_114_1619 VGND VPWR sky130_fd_sc_hd__tapvpwrvgnd_1
XFILLER_78_57 VGND VGND VPWR VPWR sky130_fd_sc_hd__decap_3
XFILLER_89_430 VGND VGND VPWR VPWR sky130_fd_sc_hd__decap_3
Xhold670 _6819_/Q VGND VGND VPWR VPWR _6819_/D sky130_fd_sc_hd__dlygate4sd3_1
Xhold681 _6862_/Q VGND VGND VPWR VPWR _6862_/D sky130_fd_sc_hd__dlygate4sd3_1
XFILLER_1_367 VGND VGND VPWR VPWR sky130_fd_sc_hd__decap_3
XFILLER_77_614 VGND VGND VPWR VPWR sky130_fd_sc_hd__fill_2
Xhold692 _6875_/Q VGND VGND VPWR VPWR _6875_/D sky130_fd_sc_hd__dlygate4sd3_1
XFILLER_103_284 VGND VGND VPWR VPWR sky130_fd_sc_hd__decap_3
XFILLER_49_316 VGND VGND VPWR VPWR sky130_fd_sc_hd__decap_3
XFILLER_77_636 VGND VGND VPWR VPWR sky130_fd_sc_hd__decap_3
XFILLER_77_669 VGND VGND VPWR VPWR sky130_fd_sc_hd__decap_3
XFILLER_94_12 VGND VGND VPWR VPWR sky130_fd_sc_hd__decap_3
XFILLER_76_168 VGND VGND VPWR VPWR sky130_fd_sc_hd__decap_3
XFILLER_91_116 VGND VGND VPWR VPWR sky130_fd_sc_hd__decap_3
XFILLER_94_56 VGND VGND VPWR VPWR sky130_fd_sc_hd__fill_2
XFILLER_17_213 VGND VGND VPWR VPWR sky130_fd_sc_hd__decap_3
XFILLER_17_246 VGND VGND VPWR VPWR sky130_fd_sc_hd__decap_3
XFILLER_27_72 VGND VGND VPWR VPWR sky130_fd_sc_hd__decap_3
XFILLER_57_382 VGND VGND VPWR VPWR sky130_fd_sc_hd__decap_3
XFILLER_72_330 VGND VGND VPWR VPWR sky130_fd_sc_hd__decap_3
XFILLER_85_691 VGND VGND VPWR VPWR sky130_fd_sc_hd__fill_1
XFILLER_72_363 VGND VGND VPWR VPWR sky130_fd_sc_hd__fill_1
XFILLER_72_396 VGND VGND VPWR VPWR sky130_fd_sc_hd__decap_3
XTAP_TAPCELL_ROW_43_767 VGND VPWR sky130_fd_sc_hd__tapvpwrvgnd_1
XTAP_TAPCELL_ROW_15_436 VGND VPWR sky130_fd_sc_hd__tapvpwrvgnd_1
XFILLER_13_474 VGND VGND VPWR VPWR sky130_fd_sc_hd__fill_2
XFILLER_43_60 VGND VGND VPWR VPWR sky130_fd_sc_hd__decap_3
XFILLER_13_496 VGND VGND VPWR VPWR sky130_fd_sc_hd__decap_3
XFILLER_4_150 VGND VGND VPWR VPWR sky130_fd_sc_hd__decap_3
XFILLER_5_662 VGND VGND VPWR VPWR sky130_fd_sc_hd__decap_3
XFILLER_5_673 VGND VGND VPWR VPWR sky130_fd_sc_hd__decap_3
XFILLER_4_21 VGND VGND VPWR VPWR sky130_fd_sc_hd__decap_3
XFILLER_4_32 VGND VGND VPWR VPWR sky130_fd_sc_hd__decap_3
XFILLER_4_65 VGND VGND VPWR VPWR sky130_fd_sc_hd__decap_3
X_4160_ _7297_/Q _4501_/S _4261_/B1 _7169_/Q _4159_/X VGND VGND VPWR VPWR _4160_/X
+ sky130_fd_sc_hd__a221o_2
XFILLER_67_113 VGND VGND VPWR VPWR sky130_fd_sc_hd__decap_3
XFILLER_95_411 VGND VGND VPWR VPWR sky130_fd_sc_hd__decap_3
XFILLER_67_146 VGND VGND VPWR VPWR sky130_fd_sc_hd__decap_3
XFILLER_68_669 VGND VGND VPWR VPWR sky130_fd_sc_hd__decap_3
XFILLER_95_455 VGND VGND VPWR VPWR sky130_fd_sc_hd__decap_3
X_4091_ _7110_/Q _4250_/A2 _4434_/B1 _7142_/Q _4090_/X VGND VGND VPWR VPWR _4091_/X
+ sky130_fd_sc_hd__a221o_2
XFILLER_82_105 VGND VGND VPWR VPWR sky130_fd_sc_hd__fill_2
XFILLER_83_617 VGND VGND VPWR VPWR sky130_fd_sc_hd__decap_3
XFILLER_75_190 VGND VGND VPWR VPWR sky130_fd_sc_hd__fill_1
XFILLER_23_205 VGND VGND VPWR VPWR sky130_fd_sc_hd__decap_3
XFILLER_91_650 VGND VGND VPWR VPWR sky130_fd_sc_hd__decap_3
Xplace330 _4289_/B VGND VGND VPWR VPWR _5708_/S sky130_fd_sc_hd__buf_2
X_6801_ _7005_/CLK _6801_/D VGND VGND VPWR VPWR _6801_/Q sky130_fd_sc_hd__dfxtp_2
XFILLER_51_547 VGND VGND VPWR VPWR sky130_fd_sc_hd__decap_3
XFILLER_90_171 VGND VGND VPWR VPWR sky130_fd_sc_hd__decap_3
Xplace363 _4265_/B VGND VGND VPWR VPWR _4432_/A2 sky130_fd_sc_hd__buf_2
Xplace352 _5159_/S VGND VGND VPWR VPWR _5157_/S sky130_fd_sc_hd__buf_2
Xplace341 _4964_/A1 VGND VGND VPWR VPWR _5092_/C sky130_fd_sc_hd__buf_2
X_4993_ _4987_/A _4991_/Y _4992_/Y VGND VGND VPWR VPWR _4993_/X sky130_fd_sc_hd__o21a_2
XFILLER_23_249 VGND VGND VPWR VPWR sky130_fd_sc_hd__decap_3
Xplace385 _5205_/B VGND VGND VPWR VPWR _5182_/B sky130_fd_sc_hd__buf_2
Xplace396 _5294_/Y VGND VGND VPWR VPWR _7412_/A sky130_fd_sc_hd__buf_2
Xplace374 _4799_/A VGND VGND VPWR VPWR _3864_/S sky130_fd_sc_hd__buf_2
X_6732_ _6978_/CLK _6732_/D VGND VGND VPWR VPWR _6732_/Q sky130_fd_sc_hd__dfxtp_2
X_6663_ _6672_/A VGND VGND VPWR VPWR _6663_/Y sky130_fd_sc_hd__inv_2
X_3875_ _3875_/A1 _5151_/A _3874_/X VGND VGND VPWR VPWR _7383_/D sky130_fd_sc_hd__o21a_2
X_6594_ _6635_/A VGND VGND VPWR VPWR _6594_/Y sky130_fd_sc_hd__inv_2
XFILLER_105_505 VGND VGND VPWR VPWR sky130_fd_sc_hd__decap_3
XFILLER_105_516 VGND VGND VPWR VPWR sky130_fd_sc_hd__decap_3
XFILLER_2_109 VGND VGND VPWR VPWR sky130_fd_sc_hd__decap_3
XFILLER_105_549 VGND VGND VPWR VPWR sky130_fd_sc_hd__fill_2
X_7215_ clkload8/A _7215_/D _6495_/Y VGND VGND VPWR VPWR _7215_/Q sky130_fd_sc_hd__dfrtp_2
XFILLER_59_614 VGND VGND VPWR VPWR sky130_fd_sc_hd__fill_2
X_7146_ _7402_/CLK _7146_/D _6426_/Y VGND VGND VPWR VPWR _7146_/Q sky130_fd_sc_hd__dfrtp_2
XFILLER_113_582 VGND VGND VPWR VPWR sky130_fd_sc_hd__decap_3
XFILLER_48_27 VGND VGND VPWR VPWR sky130_fd_sc_hd__fill_1
XFILLER_59_647 VGND VGND VPWR VPWR sky130_fd_sc_hd__decap_3
X_4358_ _4367_/A _4367_/B _4367_/C VGND VGND VPWR VPWR _5072_/B sky130_fd_sc_hd__a21bo_2
XFILLER_100_232 VGND VGND VPWR VPWR sky130_fd_sc_hd__decap_3
XFILLER_58_135 VGND VGND VPWR VPWR sky130_fd_sc_hd__decap_3
X_7077_ _7234_/CLK _7077_/D _6357_/Y VGND VGND VPWR VPWR _7077_/Q sky130_fd_sc_hd__dfrtp_2
X_4289_ _4537_/C _4289_/B VGND VGND VPWR VPWR _4649_/A sky130_fd_sc_hd__nand2_2
X_3309_ _3327_/A _3353_/A _3403_/A VGND VGND VPWR VPWR _3383_/B sky130_fd_sc_hd__or3_4
XFILLER_98_293 VGND VGND VPWR VPWR sky130_fd_sc_hd__decap_3
XFILLER_100_265 VGND VGND VPWR VPWR sky130_fd_sc_hd__fill_1
XFILLER_100_276 VGND VGND VPWR VPWR sky130_fd_sc_hd__decap_3
XFILLER_58_168 VGND VGND VPWR VPWR sky130_fd_sc_hd__decap_3
XFILLER_73_105 VGND VGND VPWR VPWR sky130_fd_sc_hd__decap_3
XFILLER_86_477 VGND VGND VPWR VPWR sky130_fd_sc_hd__decap_3
XFILLER_104_77 VGND VGND VPWR VPWR sky130_fd_sc_hd__decap_3
XFILLER_104_88 VGND VGND VPWR VPWR sky130_fd_sc_hd__decap_3
XFILLER_39_393 VGND VGND VPWR VPWR sky130_fd_sc_hd__fill_1
XFILLER_64_15 VGND VGND VPWR VPWR sky130_fd_sc_hd__decap_3
XFILLER_67_691 VGND VGND VPWR VPWR sky130_fd_sc_hd__fill_1
XFILLER_64_37 VGND VGND VPWR VPWR sky130_fd_sc_hd__decap_3
XFILLER_82_672 VGND VGND VPWR VPWR sky130_fd_sc_hd__decap_3
XFILLER_14_227 VGND VGND VPWR VPWR sky130_fd_sc_hd__decap_3
XFILLER_42_525 VGND VGND VPWR VPWR sky130_fd_sc_hd__decap_3
XFILLER_42_536 VGND VGND VPWR VPWR sky130_fd_sc_hd__fill_1
XTAP_TAPCELL_ROW_64_1017 VGND VPWR sky130_fd_sc_hd__tapvpwrvgnd_1
Xfanout20 _6632_/A VGND VGND VPWR VPWR _6567_/A sky130_fd_sc_hd__buf_2
Xfanout31 fanout38/X VGND VGND VPWR VPWR _6638_/A sky130_fd_sc_hd__clkdlybuf4s25_1
XFILLER_80_36 VGND VGND VPWR VPWR sky130_fd_sc_hd__decap_3
Xfanout42 _6547_/A VGND VGND VPWR VPWR _6578_/A sky130_fd_sc_hd__buf_2
Xfanout53 _6674_/A VGND VGND VPWR VPWR _6672_/A sky130_fd_sc_hd__buf_2
Xfanout64 fanout72/X VGND VGND VPWR VPWR _6683_/A sky130_fd_sc_hd__clkdlybuf4s25_1
XTAP_TAPCELL_ROW_40_726 VGND VPWR sky130_fd_sc_hd__tapvpwrvgnd_1
XFILLER_13_41 VGND VGND VPWR VPWR sky130_fd_sc_hd__decap_3
XFILLER_22_282 VGND VGND VPWR VPWR sky130_fd_sc_hd__decap_3
XTAP_TAPCELL_ROW_40_737 VGND VPWR sky130_fd_sc_hd__tapvpwrvgnd_1
XFILLER_10_477 VGND VGND VPWR VPWR sky130_fd_sc_hd__decap_3
XFILLER_13_63 VGND VGND VPWR VPWR sky130_fd_sc_hd__decap_3
XFILLER_108_332 VGND VGND VPWR VPWR sky130_fd_sc_hd__decap_3
XFILLER_108_343 VGND VGND VPWR VPWR sky130_fd_sc_hd__fill_2
XFILLER_6_448 VGND VGND VPWR VPWR sky130_fd_sc_hd__decap_3
XFILLER_89_12 VGND VGND VPWR VPWR sky130_fd_sc_hd__decap_3
XFILLER_108_354 VGND VGND VPWR VPWR sky130_fd_sc_hd__fill_1
XFILLER_108_365 VGND VGND VPWR VPWR sky130_fd_sc_hd__fill_2
XFILLER_108_376 VGND VGND VPWR VPWR sky130_fd_sc_hd__decap_3
XTAP_TAPCELL_ROW_20_494 VGND VPWR sky130_fd_sc_hd__tapvpwrvgnd_1
XFILLER_89_89 VGND VGND VPWR VPWR sky130_fd_sc_hd__decap_3
XTAP_TAPCELL_ROW_75_1157 VGND VPWR sky130_fd_sc_hd__tapvpwrvgnd_1
XTAP_TAPCELL_ROW_75_1146 VGND VPWR sky130_fd_sc_hd__tapvpwrvgnd_1
XFILLER_111_519 VGND VGND VPWR VPWR sky130_fd_sc_hd__fill_2
XFILLER_1_131 VGND VGND VPWR VPWR sky130_fd_sc_hd__decap_3
XFILLER_2_654 VGND VGND VPWR VPWR sky130_fd_sc_hd__decap_3
XFILLER_1_164 VGND VGND VPWR VPWR sky130_fd_sc_hd__decap_3
XFILLER_2_687 VGND VGND VPWR VPWR sky130_fd_sc_hd__decap_3
XFILLER_49_102 VGND VGND VPWR VPWR sky130_fd_sc_hd__decap_3
XFILLER_49_113 VGND VGND VPWR VPWR sky130_fd_sc_hd__decap_3
XFILLER_77_411 VGND VGND VPWR VPWR sky130_fd_sc_hd__decap_3
XFILLER_77_422 VGND VGND VPWR VPWR sky130_fd_sc_hd__decap_3
XFILLER_89_260 VGND VGND VPWR VPWR sky130_fd_sc_hd__decap_3
XFILLER_65_606 VGND VGND VPWR VPWR sky130_fd_sc_hd__decap_3
XFILLER_77_444 VGND VGND VPWR VPWR sky130_fd_sc_hd__decap_3
XFILLER_77_455 VGND VGND VPWR VPWR sky130_fd_sc_hd__decap_3
XFILLER_38_60 VGND VGND VPWR VPWR sky130_fd_sc_hd__decap_3
XFILLER_64_105 VGND VGND VPWR VPWR sky130_fd_sc_hd__decap_3
XFILLER_65_617 VGND VGND VPWR VPWR sky130_fd_sc_hd__decap_3
XTAP_TAPCELL_ROW_48_826 VGND VPWR sky130_fd_sc_hd__tapvpwrvgnd_1
XFILLER_38_82 VGND VGND VPWR VPWR sky130_fd_sc_hd__fill_2
XFILLER_64_127 VGND VGND VPWR VPWR sky130_fd_sc_hd__decap_3
XFILLER_92_436 VGND VGND VPWR VPWR sky130_fd_sc_hd__decap_3
XFILLER_33_503 VGND VGND VPWR VPWR sky130_fd_sc_hd__fill_1
XFILLER_45_363 VGND VGND VPWR VPWR sky130_fd_sc_hd__decap_3
XFILLER_73_650 VGND VGND VPWR VPWR sky130_fd_sc_hd__decap_3
XFILLER_80_609 VGND VGND VPWR VPWR sky130_fd_sc_hd__decap_3
XFILLER_92_469 VGND VGND VPWR VPWR sky130_fd_sc_hd__decap_3
XFILLER_45_396 VGND VGND VPWR VPWR sky130_fd_sc_hd__decap_3
XFILLER_72_171 VGND VGND VPWR VPWR sky130_fd_sc_hd__decap_3
XTAP_TAPCELL_ROW_86_1286 VGND VPWR sky130_fd_sc_hd__tapvpwrvgnd_1
XTAP_TAPCELL_ROW_28_583 VGND VPWR sky130_fd_sc_hd__tapvpwrvgnd_1
XFILLER_33_569 VGND VGND VPWR VPWR sky130_fd_sc_hd__decap_3
XFILLER_20_208 VGND VGND VPWR VPWR sky130_fd_sc_hd__decap_3
XFILLER_60_388 VGND VGND VPWR VPWR sky130_fd_sc_hd__decap_3
XFILLER_13_271 VGND VGND VPWR VPWR sky130_fd_sc_hd__fill_1
XFILLER_13_293 VGND VGND VPWR VPWR sky130_fd_sc_hd__decap_3
XFILLER_41_591 VGND VGND VPWR VPWR sky130_fd_sc_hd__decap_3
Xclkload12 _6946_/CLK VGND VGND VPWR VPWR clkload12/X sky130_fd_sc_hd__clkbuf_8
Xclkload23 _7234_/CLK VGND VGND VPWR VPWR clkload23/X sky130_fd_sc_hd__clkbuf_8
Xclkload34 _7337_/CLK VGND VGND VPWR VPWR clkload34/X sky130_fd_sc_hd__clkbuf_1
X_3591_ _3591_/A _3591_/B _3591_/C _3586_/D VGND VGND VPWR VPWR _3591_/Y sky130_fd_sc_hd__nor4b_2
XFILLER_55_3 VGND VGND VPWR VPWR sky130_fd_sc_hd__decap_3
XFILLER_114_324 VGND VGND VPWR VPWR sky130_fd_sc_hd__decap_3
XFILLER_114_357 VGND VGND VPWR VPWR sky130_fd_sc_hd__decap_3
XFILLER_114_379 VGND VGND VPWR VPWR sky130_fd_sc_hd__fill_1
X_7000_ _7403_/CLK _7000_/D _6280_/Y VGND VGND VPWR VPWR _7000_/Q sky130_fd_sc_hd__dfrtp_2
X_4212_ _7324_/Q _3964_/S _4348_/B1 _7132_/Q VGND VGND VPWR VPWR _4212_/X sky130_fd_sc_hd__a22o_2
XFILLER_87_219 VGND VGND VPWR VPWR sky130_fd_sc_hd__decap_3
X_5192_ _5192_/A _5225_/B VGND VGND VPWR VPWR _7232_/D sky130_fd_sc_hd__and2_2
XFILLER_68_444 VGND VGND VPWR VPWR sky130_fd_sc_hd__decap_3
X_4143_ _4845_/A _4140_/X _4142_/X VGND VGND VPWR VPWR _4143_/X sky130_fd_sc_hd__a21o_2
XFILLER_110_563 VGND VGND VPWR VPWR sky130_fd_sc_hd__decap_3
XFILLER_55_105 VGND VGND VPWR VPWR sky130_fd_sc_hd__decap_3
XFILLER_56_628 VGND VGND VPWR VPWR sky130_fd_sc_hd__decap_3
XFILLER_68_477 VGND VGND VPWR VPWR sky130_fd_sc_hd__fill_1
XFILLER_95_252 VGND VGND VPWR VPWR sky130_fd_sc_hd__fill_1
X_4074_ _7083_/Q _4432_/A2 _4432_/B1 _4073_/X VGND VGND VPWR VPWR _4451_/A sky130_fd_sc_hd__o211ai_2
XFILLER_49_691 VGND VGND VPWR VPWR sky130_fd_sc_hd__fill_1
XFILLER_55_127 VGND VGND VPWR VPWR sky130_fd_sc_hd__decap_3
XFILLER_83_436 VGND VGND VPWR VPWR sky130_fd_sc_hd__fill_2
XFILLER_83_458 VGND VGND VPWR VPWR sky130_fd_sc_hd__decap_3
XFILLER_64_672 VGND VGND VPWR VPWR sky130_fd_sc_hd__decap_3
XFILLER_34_18 VGND VGND VPWR VPWR sky130_fd_sc_hd__decap_3
XFILLER_91_491 VGND VGND VPWR VPWR sky130_fd_sc_hd__fill_1
XFILLER_51_355 VGND VGND VPWR VPWR sky130_fd_sc_hd__decap_3
XFILLER_63_193 VGND VGND VPWR VPWR sky130_fd_sc_hd__decap_3
X_6715_ _7405_/CLK _6715_/D VGND VGND VPWR VPWR _6715_/Q sky130_fd_sc_hd__dfxtp_2
X_4976_ _6992_/Q _5001_/A _6993_/Q VGND VGND VPWR VPWR _4977_/B sky130_fd_sc_hd__a21oi_2
XFILLER_51_399 VGND VGND VPWR VPWR sky130_fd_sc_hd__decap_3
X_3927_ _3629_/A _3926_/X _4466_/A VGND VGND VPWR VPWR _3927_/X sky130_fd_sc_hd__a21o_2
Xclkload6 clkload6/A VGND VGND VPWR VPWR clkload6/Y sky130_fd_sc_hd__clkinv_8
X_6646_ _6684_/A VGND VGND VPWR VPWR _6646_/Y sky130_fd_sc_hd__inv_2
X_3858_ _6698_/Q _3925_/A2 _3925_/B1 _6876_/Q VGND VGND VPWR VPWR _3858_/X sky130_fd_sc_hd__a22o_2
X_6577_ _6642_/A VGND VGND VPWR VPWR _6577_/Y sky130_fd_sc_hd__inv_2
X_3789_ _3728_/Y _3781_/X _3783_/X _3725_/X _3788_/X VGND VGND VPWR VPWR _3789_/X
+ sky130_fd_sc_hd__a221o_2
XFILLER_105_313 VGND VGND VPWR VPWR sky130_fd_sc_hd__decap_3
XFILLER_105_335 VGND VGND VPWR VPWR sky130_fd_sc_hd__fill_1
XFILLER_3_429 VGND VGND VPWR VPWR sky130_fd_sc_hd__decap_3
XFILLER_59_15 VGND VGND VPWR VPWR sky130_fd_sc_hd__decap_3
XFILLER_105_357 VGND VGND VPWR VPWR sky130_fd_sc_hd__fill_1
XFILLER_105_368 VGND VGND VPWR VPWR sky130_fd_sc_hd__decap_3
XFILLER_59_48 VGND VGND VPWR VPWR sky130_fd_sc_hd__decap_3
Xoutput550 _6983_/Q VGND VGND VPWR VPWR pc_out[6] sky130_fd_sc_hd__clkdlybuf4s25_1
XFILLER_78_219 VGND VGND VPWR VPWR sky130_fd_sc_hd__decap_3
XFILLER_115_32 VGND VGND VPWR VPWR sky130_fd_sc_hd__decap_3
XFILLER_86_241 VGND VGND VPWR VPWR sky130_fd_sc_hd__decap_3
X_7129_ clkload8/A _7129_/D _6409_/Y VGND VGND VPWR VPWR _7129_/Q sky130_fd_sc_hd__dfrtp_2
XFILLER_101_574 VGND VGND VPWR VPWR sky130_fd_sc_hd__decap_3
XFILLER_115_87 VGND VGND VPWR VPWR sky130_fd_sc_hd__decap_3
XFILLER_47_617 VGND VGND VPWR VPWR sky130_fd_sc_hd__decap_3
XFILLER_59_488 VGND VGND VPWR VPWR sky130_fd_sc_hd__decap_3
XTAP_TAPCELL_ROW_70_1087 VGND VPWR sky130_fd_sc_hd__tapvpwrvgnd_1
XFILLER_46_138 VGND VGND VPWR VPWR sky130_fd_sc_hd__fill_2
XFILLER_75_69 VGND VGND VPWR VPWR sky130_fd_sc_hd__decap_3
XFILLER_55_650 VGND VGND VPWR VPWR sky130_fd_sc_hd__decap_3
XFILLER_42_300 VGND VGND VPWR VPWR sky130_fd_sc_hd__decap_3
XFILLER_54_171 VGND VGND VPWR VPWR sky130_fd_sc_hd__decap_3
XFILLER_91_24 VGND VGND VPWR VPWR sky130_fd_sc_hd__decap_3
XFILLER_15_558 VGND VGND VPWR VPWR sky130_fd_sc_hd__fill_2
XFILLER_70_631 VGND VGND VPWR VPWR sky130_fd_sc_hd__decap_3
XFILLER_91_35 VGND VGND VPWR VPWR sky130_fd_sc_hd__fill_1
XFILLER_91_57 VGND VGND VPWR VPWR sky130_fd_sc_hd__decap_3
XFILLER_42_388 VGND VGND VPWR VPWR sky130_fd_sc_hd__decap_3
XFILLER_70_675 VGND VGND VPWR VPWR sky130_fd_sc_hd__decap_3
XTAP_TAPCELL_ROW_53_884 VGND VPWR sky130_fd_sc_hd__tapvpwrvgnd_1
XTAP_TAPCELL_ROW_25_553 VGND VPWR sky130_fd_sc_hd__tapvpwrvgnd_1
XFILLER_24_73 VGND VGND VPWR VPWR sky130_fd_sc_hd__decap_3
XFILLER_109_641 VGND VGND VPWR VPWR sky130_fd_sc_hd__decap_3
XFILLER_6_234 VGND VGND VPWR VPWR sky130_fd_sc_hd__decap_3
XFILLER_109_685 VGND VGND VPWR VPWR sky130_fd_sc_hd__decap_3
XFILLER_40_72 VGND VGND VPWR VPWR sky130_fd_sc_hd__decap_3
XFILLER_108_195 VGND VGND VPWR VPWR sky130_fd_sc_hd__fill_1
XFILLER_40_83 VGND VGND VPWR VPWR sky130_fd_sc_hd__fill_1
XFILLER_69_208 VGND VGND VPWR VPWR sky130_fd_sc_hd__decap_3
XFILLER_97_517 VGND VGND VPWR VPWR sky130_fd_sc_hd__fill_2
XFILLER_2_451 VGND VGND VPWR VPWR sky130_fd_sc_hd__decap_3
XFILLER_97_528 VGND VGND VPWR VPWR sky130_fd_sc_hd__decap_3
XFILLER_1_11 VGND VGND VPWR VPWR sky130_fd_sc_hd__decap_3
XFILLER_38_617 VGND VGND VPWR VPWR sky130_fd_sc_hd__decap_3
XFILLER_77_263 VGND VGND VPWR VPWR sky130_fd_sc_hd__decap_3
XFILLER_92_200 VGND VGND VPWR VPWR sky130_fd_sc_hd__decap_3
XTAP_TAPCELL_ROW_88_1304 VGND VPWR sky130_fd_sc_hd__tapvpwrvgnd_1
XFILLER_1_44 VGND VGND VPWR VPWR sky130_fd_sc_hd__decap_3
XFILLER_37_116 VGND VGND VPWR VPWR sky130_fd_sc_hd__decap_3
XFILLER_18_330 VGND VGND VPWR VPWR sky130_fd_sc_hd__decap_3
XFILLER_1_66 VGND VGND VPWR VPWR sky130_fd_sc_hd__decap_3
XFILLER_1_99 VGND VGND VPWR VPWR sky130_fd_sc_hd__decap_3
XFILLER_92_244 VGND VGND VPWR VPWR sky130_fd_sc_hd__decap_3
XFILLER_18_374 VGND VGND VPWR VPWR sky130_fd_sc_hd__fill_2
XFILLER_46_672 VGND VGND VPWR VPWR sky130_fd_sc_hd__decap_3
XFILLER_61_620 VGND VGND VPWR VPWR sky130_fd_sc_hd__decap_3
XFILLER_80_439 VGND VGND VPWR VPWR sky130_fd_sc_hd__decap_3
XFILLER_61_653 VGND VGND VPWR VPWR sky130_fd_sc_hd__decap_3
X_4830_ _4646_/Y _4827_/A _4829_/Y VGND VGND VPWR VPWR _4830_/X sky130_fd_sc_hd__o21a_2
XFILLER_60_174 VGND VGND VPWR VPWR sky130_fd_sc_hd__decap_3
XFILLER_33_399 VGND VGND VPWR VPWR sky130_fd_sc_hd__fill_1
X_4761_ _4762_/B _4761_/B _4761_/C VGND VGND VPWR VPWR _4761_/Y sky130_fd_sc_hd__nand3_2
X_6500_ _6568_/A VGND VGND VPWR VPWR _6500_/Y sky130_fd_sc_hd__inv_2
X_4692_ _7006_/Q _4749_/B VGND VGND VPWR VPWR _4750_/B sky130_fd_sc_hd__and2_2
X_3712_ _3746_/B VGND VGND VPWR VPWR _3741_/B sky130_fd_sc_hd__inv_2
XTAP_TAPCELL_ROW_99_1444 VGND VPWR sky130_fd_sc_hd__tapvpwrvgnd_1
X_6431_ _6637_/A VGND VGND VPWR VPWR _6431_/Y sky130_fd_sc_hd__inv_2
XFILLER_115_600 VGND VGND VPWR VPWR sky130_fd_sc_hd__decap_3
X_6362_ _6385_/A VGND VGND VPWR VPWR _6362_/Y sky130_fd_sc_hd__inv_2
XFILLER_115_644 VGND VGND VPWR VPWR sky130_fd_sc_hd__decap_3
X_3574_ _7348_/Q _4338_/B1 _3573_/X _3556_/A VGND VGND VPWR VPWR _3574_/X sky130_fd_sc_hd__a211o_2
XFILLER_114_121 VGND VGND VPWR VPWR sky130_fd_sc_hd__decap_3
X_6293_ _6535_/A VGND VGND VPWR VPWR _6293_/Y sky130_fd_sc_hd__inv_2
XFILLER_102_327 VGND VGND VPWR VPWR sky130_fd_sc_hd__decap_3
XFILLER_114_165 VGND VGND VPWR VPWR sky130_fd_sc_hd__decap_3
XFILLER_29_18 VGND VGND VPWR VPWR sky130_fd_sc_hd__fill_2
X_5175_ _5175_/A _5182_/B VGND VGND VPWR VPWR _7240_/D sky130_fd_sc_hd__and2_2
XFILLER_29_617 VGND VGND VPWR VPWR sky130_fd_sc_hd__decap_3
XFILLER_56_414 VGND VGND VPWR VPWR sky130_fd_sc_hd__decap_3
XFILLER_96_561 VGND VGND VPWR VPWR sky130_fd_sc_hd__fill_2
X_4126_ _4126_/A _4125_/X VGND VGND VPWR VPWR _4890_/B sky130_fd_sc_hd__or2b_2
XFILLER_110_371 VGND VGND VPWR VPWR sky130_fd_sc_hd__decap_3
XFILLER_56_458 VGND VGND VPWR VPWR sky130_fd_sc_hd__decap_3
XFILLER_83_266 VGND VGND VPWR VPWR sky130_fd_sc_hd__decap_3
X_4057_ _7308_/Q _4482_/S _4437_/B1 _7372_/Q _4429_/C1 VGND VGND VPWR VPWR _4057_/X
+ sky130_fd_sc_hd__a221o_2
XFILLER_43_119 VGND VGND VPWR VPWR sky130_fd_sc_hd__decap_3
XFILLER_71_417 VGND VGND VPWR VPWR sky130_fd_sc_hd__decap_3
XFILLER_83_288 VGND VGND VPWR VPWR sky130_fd_sc_hd__decap_3
XFILLER_83_299 VGND VGND VPWR VPWR sky130_fd_sc_hd__decap_3
XTAP_TAPCELL_ROW_108_1551 VGND VPWR sky130_fd_sc_hd__tapvpwrvgnd_1
XFILLER_101_23 VGND VGND VPWR VPWR sky130_fd_sc_hd__decap_3
XFILLER_36_193 VGND VGND VPWR VPWR sky130_fd_sc_hd__decap_3
XFILLER_52_631 VGND VGND VPWR VPWR sky130_fd_sc_hd__decap_3
XFILLER_24_388 VGND VGND VPWR VPWR sky130_fd_sc_hd__decap_3
XFILLER_52_675 VGND VGND VPWR VPWR sky130_fd_sc_hd__decap_3
XFILLER_101_89 VGND VGND VPWR VPWR sky130_fd_sc_hd__decap_3
XFILLER_51_185 VGND VGND VPWR VPWR sky130_fd_sc_hd__decap_3
XFILLER_61_27 VGND VGND VPWR VPWR sky130_fd_sc_hd__decap_3
X_4959_ _6993_/Q _4958_/Y _6994_/Q VGND VGND VPWR VPWR _4960_/C sky130_fd_sc_hd__a21oi_2
XTAP_TAPCELL_ROW_22_512 VGND VPWR sky130_fd_sc_hd__tapvpwrvgnd_1
XTAP_TAPCELL_ROW_50_854 VGND VPWR sky130_fd_sc_hd__tapvpwrvgnd_1
X_6629_ _6660_/A VGND VGND VPWR VPWR _6629_/Y sky130_fd_sc_hd__inv_2
XFILLER_106_600 VGND VGND VPWR VPWR sky130_fd_sc_hd__decap_3
XFILLER_106_633 VGND VGND VPWR VPWR sky130_fd_sc_hd__decap_3
XFILLER_106_666 VGND VGND VPWR VPWR sky130_fd_sc_hd__decap_3
XFILLER_10_53 VGND VGND VPWR VPWR sky130_fd_sc_hd__decap_3
XFILLER_3_237 VGND VGND VPWR VPWR sky130_fd_sc_hd__decap_3
XTAP_TAPCELL_ROW_72_1116 VGND VPWR sky130_fd_sc_hd__tapvpwrvgnd_1
XFILLER_105_154 VGND VGND VPWR VPWR sky130_fd_sc_hd__fill_1
XFILLER_105_165 VGND VGND VPWR VPWR sky130_fd_sc_hd__decap_3
XFILLER_10_97 VGND VGND VPWR VPWR sky130_fd_sc_hd__decap_3
XFILLER_47_414 VGND VGND VPWR VPWR sky130_fd_sc_hd__decap_3
XFILLER_86_79 VGND VGND VPWR VPWR sky130_fd_sc_hd__decap_3
XFILLER_87_572 VGND VGND VPWR VPWR sky130_fd_sc_hd__fill_1
XFILLER_101_371 VGND VGND VPWR VPWR sky130_fd_sc_hd__decap_3
XFILLER_101_393 VGND VGND VPWR VPWR sky130_fd_sc_hd__decap_3
XFILLER_19_116 VGND VGND VPWR VPWR sky130_fd_sc_hd__decap_3
XFILLER_19_73 VGND VGND VPWR VPWR sky130_fd_sc_hd__decap_3
XFILLER_59_274 VGND VGND VPWR VPWR sky130_fd_sc_hd__decap_3
XFILLER_74_200 VGND VGND VPWR VPWR sky130_fd_sc_hd__decap_3
XTAP_TAPCELL_ROW_58_943 VGND VPWR sky130_fd_sc_hd__tapvpwrvgnd_1
XFILLER_19_95 VGND VGND VPWR VPWR sky130_fd_sc_hd__decap_3
XFILLER_62_417 VGND VGND VPWR VPWR sky130_fd_sc_hd__decap_3
XTAP_TAPCELL_ROW_2_281 VGND VPWR sky130_fd_sc_hd__tapvpwrvgnd_1
XTAP_TAPCELL_ROW_2_270 VGND VPWR sky130_fd_sc_hd__tapvpwrvgnd_1
XFILLER_43_642 VGND VGND VPWR VPWR sky130_fd_sc_hd__decap_3
XTAP_TAPCELL_ROW_83_1245 VGND VPWR sky130_fd_sc_hd__tapvpwrvgnd_1
XFILLER_42_141 VGND VGND VPWR VPWR sky130_fd_sc_hd__decap_3
XFILLER_15_399 VGND VGND VPWR VPWR sky130_fd_sc_hd__decap_3
XFILLER_30_336 VGND VGND VPWR VPWR sky130_fd_sc_hd__decap_3
XFILLER_70_483 VGND VGND VPWR VPWR sky130_fd_sc_hd__decap_3
XFILLER_89_9 VGND VGND VPWR VPWR sky130_fd_sc_hd__decap_3
XFILLER_11_594 VGND VGND VPWR VPWR sky130_fd_sc_hd__decap_3
XFILLER_51_60 VGND VGND VPWR VPWR sky130_fd_sc_hd__decap_3
XTAP_TAPCELL_ROW_94_1374 VGND VPWR sky130_fd_sc_hd__tapvpwrvgnd_1
XFILLER_111_102 VGND VGND VPWR VPWR sky130_fd_sc_hd__decap_3
XFILLER_112_625 VGND VGND VPWR VPWR sky130_fd_sc_hd__decap_3
XFILLER_97_314 VGND VGND VPWR VPWR sky130_fd_sc_hd__decap_3
XTAP_TAPCELL_ROW_94_1385 VGND VPWR sky130_fd_sc_hd__tapvpwrvgnd_1
XFILLER_111_113 VGND VGND VPWR VPWR sky130_fd_sc_hd__decap_3
XFILLER_112_669 VGND VGND VPWR VPWR sky130_fd_sc_hd__decap_3
XFILLER_2_270 VGND VGND VPWR VPWR sky130_fd_sc_hd__fill_1
XFILLER_2_292 VGND VGND VPWR VPWR sky130_fd_sc_hd__decap_3
XFILLER_111_146 VGND VGND VPWR VPWR sky130_fd_sc_hd__decap_3
XFILLER_18_3 VGND VGND VPWR VPWR sky130_fd_sc_hd__decap_3
XFILLER_93_553 VGND VGND VPWR VPWR sky130_fd_sc_hd__decap_3
X_6980_ _7265_/CLK _6980_/D _6260_/Y VGND VGND VPWR VPWR _6980_/Q sky130_fd_sc_hd__dfrtp_2
XFILLER_53_417 VGND VGND VPWR VPWR sky130_fd_sc_hd__decap_3
XFILLER_53_439 VGND VGND VPWR VPWR sky130_fd_sc_hd__decap_3
XFILLER_34_642 VGND VGND VPWR VPWR sky130_fd_sc_hd__fill_2
XFILLER_33_152 VGND VGND VPWR VPWR sky130_fd_sc_hd__decap_3
XFILLER_21_314 VGND VGND VPWR VPWR sky130_fd_sc_hd__fill_1
XFILLER_33_196 VGND VGND VPWR VPWR sky130_fd_sc_hd__decap_3
X_4813_ _4813_/A _4813_/B VGND VGND VPWR VPWR _4813_/Y sky130_fd_sc_hd__nand2_2
X_4744_ _4938_/A _4744_/B VGND VGND VPWR VPWR _4744_/Y sky130_fd_sc_hd__nor2_2
XTAP_TAPCELL_ROW_103_1492 VGND VPWR sky130_fd_sc_hd__tapvpwrvgnd_1
X_4675_ _4799_/A _3469_/B _3564_/X _3449_/A _6984_/Q VGND VGND VPWR VPWR _5067_/B
+ sky130_fd_sc_hd__o2111a_2
X_7394_ _7398_/CLK _7394_/D _6674_/Y VGND VGND VPWR VPWR _7394_/Q sky130_fd_sc_hd__dfrtp_2
X_6414_ _6576_/A VGND VGND VPWR VPWR _6414_/Y sky130_fd_sc_hd__inv_2
X_3626_ _3616_/Y _3617_/X _3625_/X VGND VGND VPWR VPWR _3733_/C sky130_fd_sc_hd__a21oi_4
X_6345_ _6540_/A VGND VGND VPWR VPWR _6345_/Y sky130_fd_sc_hd__inv_2
X_3557_ _7221_/Q _3377_/X _4303_/B1 _7125_/Q _3556_/X VGND VGND VPWR VPWR _3557_/X
+ sky130_fd_sc_hd__a221o_2
X_6276_ _6280_/A VGND VGND VPWR VPWR _6276_/Y sky130_fd_sc_hd__inv_2
XFILLER_102_113 VGND VGND VPWR VPWR sky130_fd_sc_hd__fill_1
XFILLER_103_647 VGND VGND VPWR VPWR sky130_fd_sc_hd__decap_3
X_5227_ _5227_/A1 _5205_/B _5655_/B VGND VGND VPWR VPWR _7215_/D sky130_fd_sc_hd__a21o_2
X_3488_ _7279_/Q _4503_/S VGND VGND VPWR VPWR _3488_/X sky130_fd_sc_hd__and2_2
XFILLER_111_691 VGND VGND VPWR VPWR sky130_fd_sc_hd__fill_1
XFILLER_29_414 VGND VGND VPWR VPWR sky130_fd_sc_hd__decap_3
XFILLER_69_594 VGND VGND VPWR VPWR sky130_fd_sc_hd__fill_1
XFILLER_56_233 VGND VGND VPWR VPWR sky130_fd_sc_hd__decap_3
X_5089_ _3618_/C _4315_/A _5086_/A _5101_/A _5088_/X VGND VGND VPWR VPWR _5089_/Y
+ sky130_fd_sc_hd__o221ai_2
X_4109_ _4376_/A _4141_/A _4141_/B _4142_/C VGND VGND VPWR VPWR _4109_/X sky130_fd_sc_hd__o31a_2
XFILLER_112_11 VGND VGND VPWR VPWR sky130_fd_sc_hd__decap_3
XFILLER_56_277 VGND VGND VPWR VPWR sky130_fd_sc_hd__decap_3
XFILLER_84_586 VGND VGND VPWR VPWR sky130_fd_sc_hd__fill_2
XTAP_TAPCELL_ROW_55_913 VGND VPWR sky130_fd_sc_hd__tapvpwrvgnd_1
XFILLER_112_44 VGND VGND VPWR VPWR sky130_fd_sc_hd__decap_3
XFILLER_112_77 VGND VGND VPWR VPWR sky130_fd_sc_hd__decap_3
XFILLER_72_15 VGND VGND VPWR VPWR sky130_fd_sc_hd__decap_3
XFILLER_112_88 VGND VGND VPWR VPWR sky130_fd_sc_hd__decap_3
XFILLER_24_141 VGND VGND VPWR VPWR sky130_fd_sc_hd__fill_1
XFILLER_72_37 VGND VGND VPWR VPWR sky130_fd_sc_hd__fill_2
XFILLER_24_185 VGND VGND VPWR VPWR sky130_fd_sc_hd__decap_3
XFILLER_52_472 VGND VGND VPWR VPWR sky130_fd_sc_hd__decap_3
XTAP_TAPCELL_ROW_35_670 VGND VPWR sky130_fd_sc_hd__tapvpwrvgnd_1
XFILLER_21_41 VGND VGND VPWR VPWR sky130_fd_sc_hd__fill_2
XFILLER_21_63 VGND VGND VPWR VPWR sky130_fd_sc_hd__decap_3
XFILLER_97_12 VGND VGND VPWR VPWR sky130_fd_sc_hd__decap_3
XFILLER_106_463 VGND VGND VPWR VPWR sky130_fd_sc_hd__decap_3
XFILLER_106_496 VGND VGND VPWR VPWR sky130_fd_sc_hd__decap_3
XTAP_TAPCELL_ROW_7_340 VGND VPWR sky130_fd_sc_hd__tapvpwrvgnd_1
XFILLER_47_211 VGND VGND VPWR VPWR sky130_fd_sc_hd__fill_2
XFILLER_47_222 VGND VGND VPWR VPWR sky130_fd_sc_hd__fill_2
XFILLER_35_417 VGND VGND VPWR VPWR sky130_fd_sc_hd__fill_1
XFILLER_62_214 VGND VGND VPWR VPWR sky130_fd_sc_hd__decap_3
XFILLER_28_480 VGND VGND VPWR VPWR sky130_fd_sc_hd__fill_1
XFILLER_35_439 VGND VGND VPWR VPWR sky130_fd_sc_hd__decap_3
XFILLER_47_299 VGND VGND VPWR VPWR sky130_fd_sc_hd__decap_3
XFILLER_90_545 VGND VGND VPWR VPWR sky130_fd_sc_hd__decap_3
XFILLER_43_461 VGND VGND VPWR VPWR sky130_fd_sc_hd__decap_3
XFILLER_30_100 VGND VGND VPWR VPWR sky130_fd_sc_hd__decap_3
XFILLER_30_111 VGND VGND VPWR VPWR sky130_fd_sc_hd__decap_3
XFILLER_70_280 VGND VGND VPWR VPWR sky130_fd_sc_hd__decap_3
XFILLER_30_133 VGND VGND VPWR VPWR sky130_fd_sc_hd__fill_2
XFILLER_31_667 VGND VGND VPWR VPWR sky130_fd_sc_hd__decap_3
XFILLER_87_6 VGND VGND VPWR VPWR sky130_fd_sc_hd__decap_3
XFILLER_30_177 VGND VGND VPWR VPWR sky130_fd_sc_hd__decap_3
XFILLER_7_21 VGND VGND VPWR VPWR sky130_fd_sc_hd__decap_3
XFILLER_11_391 VGND VGND VPWR VPWR sky130_fd_sc_hd__fill_1
XFILLER_7_340 VGND VGND VPWR VPWR sky130_fd_sc_hd__decap_3
XFILLER_7_54 VGND VGND VPWR VPWR sky130_fd_sc_hd__fill_2
XTAP_TAPCELL_ROW_96_1403 VGND VPWR sky130_fd_sc_hd__tapvpwrvgnd_1
XFILLER_7_373 VGND VGND VPWR VPWR sky130_fd_sc_hd__decap_3
XFILLER_7_87 VGND VGND VPWR VPWR sky130_fd_sc_hd__decap_3
X_4460_ _4460_/A _4460_/B VGND VGND VPWR VPWR _4460_/Y sky130_fd_sc_hd__nand2_2
XFILLER_109_290 VGND VGND VPWR VPWR sky130_fd_sc_hd__decap_3
X_4391_ _7401_/Q _4429_/B1 _4436_/B1 _7177_/Q _4390_/X VGND VGND VPWR VPWR _4391_/X
+ sky130_fd_sc_hd__a221o_2
X_3342_ _6983_/Q _3342_/B VGND VGND VPWR VPWR _5118_/D sky130_fd_sc_hd__nand2b_4
XFILLER_98_612 VGND VGND VPWR VPWR sky130_fd_sc_hd__decap_3
XFILLER_3_590 VGND VGND VPWR VPWR sky130_fd_sc_hd__decap_3
XFILLER_98_645 VGND VGND VPWR VPWR sky130_fd_sc_hd__decap_3
XFILLER_112_477 VGND VGND VPWR VPWR sky130_fd_sc_hd__decap_3
XFILLER_58_509 VGND VGND VPWR VPWR sky130_fd_sc_hd__decap_3
XFILLER_85_317 VGND VGND VPWR VPWR sky130_fd_sc_hd__decap_3
XFILLER_97_166 VGND VGND VPWR VPWR sky130_fd_sc_hd__fill_2
XFILLER_98_678 VGND VGND VPWR VPWR sky130_fd_sc_hd__decap_3
XFILLER_85_328 VGND VGND VPWR VPWR sky130_fd_sc_hd__decap_3
XFILLER_97_199 VGND VGND VPWR VPWR sky130_fd_sc_hd__decap_3
Xhold1007 _7397_/Q VGND VGND VPWR VPWR _3754_/A1 sky130_fd_sc_hd__dlygate4sd3_1
Xhold1018 _7260_/Q VGND VGND VPWR VPWR _5028_/A0 sky130_fd_sc_hd__dlygate4sd3_1
Xhold1029 _7186_/Q VGND VGND VPWR VPWR _5286_/A0 sky130_fd_sc_hd__dlygate4sd3_1
X_5012_ _5012_/A0 _5011_/X _5028_/S VGND VGND VPWR VPWR _7261_/D sky130_fd_sc_hd__mux2_2
XFILLER_66_553 VGND VGND VPWR VPWR sky130_fd_sc_hd__decap_3
XFILLER_81_501 VGND VGND VPWR VPWR sky130_fd_sc_hd__decap_3
XFILLER_93_350 VGND VGND VPWR VPWR sky130_fd_sc_hd__decap_3
XFILLER_53_225 VGND VGND VPWR VPWR sky130_fd_sc_hd__decap_3
X_6963_ _6978_/CLK _6963_/D VGND VGND VPWR VPWR _6963_/Q sky130_fd_sc_hd__dfxtp_2
XTAP_TAPCELL_ROW_105_1510 VGND VPWR sky130_fd_sc_hd__tapvpwrvgnd_1
XFILLER_41_409 VGND VGND VPWR VPWR sky130_fd_sc_hd__decap_3
XFILLER_53_258 VGND VGND VPWR VPWR sky130_fd_sc_hd__decap_3
X_6894_ _7392_/CLK _6894_/D VGND VGND VPWR VPWR _6894_/Q sky130_fd_sc_hd__dfxtp_2
XFILLER_42_18 VGND VGND VPWR VPWR sky130_fd_sc_hd__decap_3
XFILLER_42_29 VGND VGND VPWR VPWR sky130_fd_sc_hd__fill_2
XTAP_TAPCELL_ROW_32_640 VGND VPWR sky130_fd_sc_hd__tapvpwrvgnd_1
XTAP_TAPCELL_ROW_60_971 VGND VPWR sky130_fd_sc_hd__tapvpwrvgnd_1
X_4727_ _7007_/Q _4750_/B _4983_/A VGND VGND VPWR VPWR _4728_/B sky130_fd_sc_hd__o21a_2
X_4658_ _4658_/A _4658_/B VGND VGND VPWR VPWR _4658_/Y sky130_fd_sc_hd__nand2_2
Xhold830 _6773_/Q VGND VGND VPWR VPWR _6773_/D sky130_fd_sc_hd__dlygate4sd3_1
X_3609_ _5071_/A _5114_/A VGND VGND VPWR VPWR _3610_/B sky130_fd_sc_hd__nand2_2
XTAP_TAPCELL_ROW_116_1661 VGND VPWR sky130_fd_sc_hd__tapvpwrvgnd_1
XTAP_TAPCELL_ROW_116_1650 VGND VPWR sky130_fd_sc_hd__tapvpwrvgnd_1
XFILLER_107_11 VGND VGND VPWR VPWR sky130_fd_sc_hd__decap_3
XFILLER_89_601 VGND VGND VPWR VPWR sky130_fd_sc_hd__decap_3
XFILLER_89_623 VGND VGND VPWR VPWR sky130_fd_sc_hd__decap_3
X_7377_ clkload9/A _7377_/D _6657_/Y VGND VGND VPWR VPWR _7377_/Q sky130_fd_sc_hd__dfrtp_2
Xhold841 _6942_/Q VGND VGND VPWR VPWR _6942_/D sky130_fd_sc_hd__dlygate4sd3_1
Xhold852 _7065_/Q VGND VGND VPWR VPWR _7065_/D sky130_fd_sc_hd__dlygate4sd3_1
Xhold863 _7115_/Q VGND VGND VPWR VPWR _7115_/D sky130_fd_sc_hd__dlygate4sd3_1
X_4589_ _4589_/A _4595_/B VGND VGND VPWR VPWR _7286_/D sky130_fd_sc_hd__and2_2
XFILLER_103_422 VGND VGND VPWR VPWR sky130_fd_sc_hd__decap_3
XFILLER_107_44 VGND VGND VPWR VPWR sky130_fd_sc_hd__decap_3
XFILLER_107_66 VGND VGND VPWR VPWR sky130_fd_sc_hd__decap_3
XFILLER_115_293 VGND VGND VPWR VPWR sky130_fd_sc_hd__decap_3
XFILLER_88_111 VGND VGND VPWR VPWR sky130_fd_sc_hd__decap_3
XFILLER_89_656 VGND VGND VPWR VPWR sky130_fd_sc_hd__decap_3
Xhold874 _7107_/Q VGND VGND VPWR VPWR _7107_/D sky130_fd_sc_hd__dlygate4sd3_1
Xhold885 _7063_/Q VGND VGND VPWR VPWR _7063_/D sky130_fd_sc_hd__dlygate4sd3_1
Xhold896 _7099_/Q VGND VGND VPWR VPWR _7099_/D sky130_fd_sc_hd__dlygate4sd3_1
X_6328_ _6675_/A VGND VGND VPWR VPWR _6328_/Y sky130_fd_sc_hd__inv_2
XFILLER_103_444 VGND VGND VPWR VPWR sky130_fd_sc_hd__decap_3
XFILLER_107_99 VGND VGND VPWR VPWR sky130_fd_sc_hd__decap_3
XFILLER_67_15 VGND VGND VPWR VPWR sky130_fd_sc_hd__decap_3
XFILLER_67_48 VGND VGND VPWR VPWR sky130_fd_sc_hd__decap_3
XFILLER_88_155 VGND VGND VPWR VPWR sky130_fd_sc_hd__decap_3
X_6259_ _6385_/A VGND VGND VPWR VPWR _6259_/Y sky130_fd_sc_hd__inv_2
XFILLER_76_339 VGND VGND VPWR VPWR sky130_fd_sc_hd__fill_2
XFILLER_57_564 VGND VGND VPWR VPWR sky130_fd_sc_hd__decap_3
XFILLER_57_597 VGND VGND VPWR VPWR sky130_fd_sc_hd__decap_3
XFILLER_72_523 VGND VGND VPWR VPWR sky130_fd_sc_hd__decap_3
XFILLER_84_350 VGND VGND VPWR VPWR sky130_fd_sc_hd__decap_3
XFILLER_44_225 VGND VGND VPWR VPWR sky130_fd_sc_hd__decap_3
XFILLER_13_601 VGND VGND VPWR VPWR sky130_fd_sc_hd__decap_3
XFILLER_16_41 VGND VGND VPWR VPWR sky130_fd_sc_hd__decap_3
XFILLER_25_461 VGND VGND VPWR VPWR sky130_fd_sc_hd__decap_3
XFILLER_72_567 VGND VGND VPWR VPWR sky130_fd_sc_hd__decap_3
XFILLER_72_589 VGND VGND VPWR VPWR sky130_fd_sc_hd__decap_3
XTAP_TAPCELL_ROW_67_1059 VGND VPWR sky130_fd_sc_hd__tapvpwrvgnd_1
XFILLER_13_634 VGND VGND VPWR VPWR sky130_fd_sc_hd__fill_2
XFILLER_16_74 VGND VGND VPWR VPWR sky130_fd_sc_hd__decap_3
XFILLER_16_85 VGND VGND VPWR VPWR sky130_fd_sc_hd__decap_3
XTAP_TAPCELL_ROW_80_1215 VGND VPWR sky130_fd_sc_hd__tapvpwrvgnd_1
XPHY_EDGE_ROW_11_Right_11 VGND VGND VPWR VPWR sky130_fd_sc_hd__decap_3
XFILLER_12_122 VGND VGND VPWR VPWR sky130_fd_sc_hd__fill_2
XFILLER_12_144 VGND VGND VPWR VPWR sky130_fd_sc_hd__decap_3
XFILLER_13_656 VGND VGND VPWR VPWR sky130_fd_sc_hd__decap_3
XFILLER_8_115 VGND VGND VPWR VPWR sky130_fd_sc_hd__decap_3
XTAP_TAPCELL_ROW_10_367 VGND VPWR sky130_fd_sc_hd__tapvpwrvgnd_1
XFILLER_113_208 VGND VGND VPWR VPWR sky130_fd_sc_hd__decap_3
XFILLER_4_365 VGND VGND VPWR VPWR sky130_fd_sc_hd__fill_2
XTAP_TAPCELL_ROW_78_1188 VGND VPWR sky130_fd_sc_hd__tapvpwrvgnd_1
XFILLER_106_271 VGND VGND VPWR VPWR sky130_fd_sc_hd__decap_3
XTAP_TAPCELL_ROW_91_1344 VGND VPWR sky130_fd_sc_hd__tapvpwrvgnd_1
XPHY_EDGE_ROW_20_Right_20 VGND VGND VPWR VPWR sky130_fd_sc_hd__decap_3
XFILLER_79_155 VGND VGND VPWR VPWR sky130_fd_sc_hd__decap_3
XFILLER_94_103 VGND VGND VPWR VPWR sky130_fd_sc_hd__fill_2
XFILLER_95_626 VGND VGND VPWR VPWR sky130_fd_sc_hd__decap_3
XFILLER_82_309 VGND VGND VPWR VPWR sky130_fd_sc_hd__decap_3
XFILLER_94_147 VGND VGND VPWR VPWR sky130_fd_sc_hd__fill_1
XFILLER_95_659 VGND VGND VPWR VPWR sky130_fd_sc_hd__decap_3
XFILLER_48_586 VGND VGND VPWR VPWR sky130_fd_sc_hd__fill_2
XFILLER_35_214 VGND VGND VPWR VPWR sky130_fd_sc_hd__decap_3
XFILLER_35_225 VGND VGND VPWR VPWR sky130_fd_sc_hd__decap_3
XFILLER_16_450 VGND VGND VPWR VPWR sky130_fd_sc_hd__fill_2
XFILLER_63_589 VGND VGND VPWR VPWR sky130_fd_sc_hd__decap_3
X_3960_ _7360_/Q _4503_/A0 _3968_/S VGND VGND VPWR VPWR _7360_/D sky130_fd_sc_hd__mux2_2
XTAP_TAPCELL_ROW_18_467 VGND VPWR sky130_fd_sc_hd__tapvpwrvgnd_1
XFILLER_16_461 VGND VGND VPWR VPWR sky130_fd_sc_hd__fill_1
XFILLER_31_420 VGND VGND VPWR VPWR sky130_fd_sc_hd__decap_3
XFILLER_50_228 VGND VGND VPWR VPWR sky130_fd_sc_hd__decap_3
XTAP_TAPCELL_ROW_46_798 VGND VPWR sky130_fd_sc_hd__tapvpwrvgnd_1
X_3891_ _6951_/Q _3651_/Y _3892_/B1 _6957_/Q _3890_/X VGND VGND VPWR VPWR _3891_/X
+ sky130_fd_sc_hd__a221o_2
XFILLER_31_464 VGND VGND VPWR VPWR sky130_fd_sc_hd__fill_1
X_5630_ _5630_/A _5634_/B VGND VGND VPWR VPWR _7013_/D sky130_fd_sc_hd__and2_2
XTAP_TAPCELL_ROW_100_1451 VGND VPWR sky130_fd_sc_hd__tapvpwrvgnd_1
X_5561_ _5561_/A1 _4983_/A _4695_/X VGND VGND VPWR VPWR _7054_/D sky130_fd_sc_hd__o21a_2
XFILLER_8_671 VGND VGND VPWR VPWR sky130_fd_sc_hd__decap_3
X_7300_ _7397_/CLK _7300_/D _6580_/Y VGND VGND VPWR VPWR _7300_/Q sky130_fd_sc_hd__dfrtp_2
XFILLER_7_181 VGND VGND VPWR VPWR sky130_fd_sc_hd__decap_3
X_7231_ _7266_/CLK _7231_/D _6511_/Y VGND VGND VPWR VPWR _7231_/Q sky130_fd_sc_hd__dfrtp_2
X_4443_ _4778_/A _4778_/B _4647_/C _4787_/A _4779_/A VGND VGND VPWR VPWR _4761_/B
+ sky130_fd_sc_hd__a2111o_2
X_7162_ clkload8/A _7162_/D _6442_/Y VGND VGND VPWR VPWR _7162_/Q sky130_fd_sc_hd__dfrtp_2
X_4374_ _4371_/Y _4224_/C _4373_/Y VGND VGND VPWR VPWR _4374_/X sky130_fd_sc_hd__o21a_2
XFILLER_112_230 VGND VGND VPWR VPWR sky130_fd_sc_hd__decap_3
XFILLER_86_615 VGND VGND VPWR VPWR sky130_fd_sc_hd__decap_3
X_7093_ clkload5/A _7093_/D _6373_/Y VGND VGND VPWR VPWR _7093_/Q sky130_fd_sc_hd__dfrtp_2
X_3325_ _3323_/X _3324_/X _4697_/A VGND VGND VPWR VPWR _3326_/B sky130_fd_sc_hd__a21oi_2
XFILLER_98_464 VGND VGND VPWR VPWR sky130_fd_sc_hd__decap_3
XFILLER_98_453 VGND VGND VPWR VPWR sky130_fd_sc_hd__decap_3
XFILLER_58_339 VGND VGND VPWR VPWR sky130_fd_sc_hd__decap_3
XFILLER_85_103 VGND VGND VPWR VPWR sky130_fd_sc_hd__decap_3
XFILLER_86_648 VGND VGND VPWR VPWR sky130_fd_sc_hd__decap_3
XTAP_TAPCELL_ROW_111_1580 VGND VPWR sky130_fd_sc_hd__tapvpwrvgnd_1
XFILLER_100_469 VGND VGND VPWR VPWR sky130_fd_sc_hd__decap_3
XFILLER_37_18 VGND VGND VPWR VPWR sky130_fd_sc_hd__decap_3
XFILLER_26_203 VGND VGND VPWR VPWR sky130_fd_sc_hd__decap_3
XFILLER_39_564 VGND VGND VPWR VPWR sky130_fd_sc_hd__decap_3
XFILLER_94_681 VGND VGND VPWR VPWR sky130_fd_sc_hd__decap_3
XFILLER_54_523 VGND VGND VPWR VPWR sky130_fd_sc_hd__decap_3
XFILLER_81_320 VGND VGND VPWR VPWR sky130_fd_sc_hd__decap_3
XFILLER_93_180 VGND VGND VPWR VPWR sky130_fd_sc_hd__fill_1
XFILLER_54_589 VGND VGND VPWR VPWR sky130_fd_sc_hd__decap_3
XFILLER_81_353 VGND VGND VPWR VPWR sky130_fd_sc_hd__decap_3
X_6946_ _6946_/CLK _6946_/D VGND VGND VPWR VPWR _6946_/Q sky130_fd_sc_hd__dfxtp_2
XFILLER_41_217 VGND VGND VPWR VPWR sky130_fd_sc_hd__decap_3
XFILLER_41_228 VGND VGND VPWR VPWR sky130_fd_sc_hd__decap_3
XFILLER_53_39 VGND VGND VPWR VPWR sky130_fd_sc_hd__decap_3
X_6877_ clkload2/A _6877_/D VGND VGND VPWR VPWR _6877_/Q sky130_fd_sc_hd__dfxtp_2
XFILLER_22_475 VGND VGND VPWR VPWR sky130_fd_sc_hd__fill_1
XFILLER_10_659 VGND VGND VPWR VPWR sky130_fd_sc_hd__decap_3
XFILLER_6_619 VGND VGND VPWR VPWR sky130_fd_sc_hd__decap_3
XFILLER_116_580 VGND VGND VPWR VPWR sky130_fd_sc_hd__decap_3
XFILLER_78_25 VGND VGND VPWR VPWR sky130_fd_sc_hd__decap_3
Xhold660 _6803_/Q VGND VGND VPWR VPWR _6803_/D sky130_fd_sc_hd__dlygate4sd3_1
Xhold671 _6834_/Q VGND VGND VPWR VPWR _6834_/D sky130_fd_sc_hd__dlygate4sd3_1
XFILLER_103_230 VGND VGND VPWR VPWR sky130_fd_sc_hd__decap_3
Xhold682 _6924_/Q VGND VGND VPWR VPWR _6924_/D sky130_fd_sc_hd__dlygate4sd3_1
Xhold693 _6897_/Q VGND VGND VPWR VPWR _6897_/D sky130_fd_sc_hd__dlygate4sd3_1
XFILLER_103_263 VGND VGND VPWR VPWR sky130_fd_sc_hd__decap_3
XFILLER_1_379 VGND VGND VPWR VPWR sky130_fd_sc_hd__decap_3
XFILLER_49_328 VGND VGND VPWR VPWR sky130_fd_sc_hd__decap_3
XFILLER_77_648 VGND VGND VPWR VPWR sky130_fd_sc_hd__decap_3
XFILLER_103_296 VGND VGND VPWR VPWR sky130_fd_sc_hd__decap_3
XFILLER_76_147 VGND VGND VPWR VPWR sky130_fd_sc_hd__decap_3
XFILLER_57_361 VGND VGND VPWR VPWR sky130_fd_sc_hd__decap_3
XFILLER_92_629 VGND VGND VPWR VPWR sky130_fd_sc_hd__decap_3
XFILLER_94_46 VGND VGND VPWR VPWR sky130_fd_sc_hd__fill_1
XFILLER_17_225 VGND VGND VPWR VPWR sky130_fd_sc_hd__decap_3
XFILLER_27_51 VGND VGND VPWR VPWR sky130_fd_sc_hd__decap_3
XFILLER_91_128 VGND VGND VPWR VPWR sky130_fd_sc_hd__decap_3
XFILLER_17_258 VGND VGND VPWR VPWR sky130_fd_sc_hd__decap_3
XFILLER_17_269 VGND VGND VPWR VPWR sky130_fd_sc_hd__decap_3
XFILLER_27_84 VGND VGND VPWR VPWR sky130_fd_sc_hd__decap_3
XFILLER_72_342 VGND VGND VPWR VPWR sky130_fd_sc_hd__decap_3
XFILLER_32_206 VGND VGND VPWR VPWR sky130_fd_sc_hd__decap_3
XFILLER_32_228 VGND VGND VPWR VPWR sky130_fd_sc_hd__decap_3
XTAP_TAPCELL_ROW_15_426 VGND VPWR sky130_fd_sc_hd__tapvpwrvgnd_1
XTAP_TAPCELL_ROW_43_768 VGND VPWR sky130_fd_sc_hd__tapvpwrvgnd_1
XTAP_TAPCELL_ROW_15_437 VGND VPWR sky130_fd_sc_hd__tapvpwrvgnd_1
XFILLER_13_464 VGND VGND VPWR VPWR sky130_fd_sc_hd__fill_2
XFILLER_40_250 VGND VGND VPWR VPWR sky130_fd_sc_hd__fill_2
XFILLER_9_402 VGND VGND VPWR VPWR sky130_fd_sc_hd__decap_3
XFILLER_71_9 VGND VGND VPWR VPWR sky130_fd_sc_hd__decap_3
XFILLER_114_506 VGND VGND VPWR VPWR sky130_fd_sc_hd__fill_1
XFILLER_114_528 VGND VGND VPWR VPWR sky130_fd_sc_hd__decap_3
XFILLER_114_539 VGND VGND VPWR VPWR sky130_fd_sc_hd__decap_3
XFILLER_4_162 VGND VGND VPWR VPWR sky130_fd_sc_hd__decap_3
XFILLER_5_685 VGND VGND VPWR VPWR sky130_fd_sc_hd__decap_3
XFILLER_99_239 VGND VGND VPWR VPWR sky130_fd_sc_hd__decap_3
XFILLER_4_44 VGND VGND VPWR VPWR sky130_fd_sc_hd__decap_3
XFILLER_4_77 VGND VGND VPWR VPWR sky130_fd_sc_hd__decap_3
XFILLER_4_88 VGND VGND VPWR VPWR sky130_fd_sc_hd__decap_3
XFILLER_68_626 VGND VGND VPWR VPWR sky130_fd_sc_hd__decap_3
XFILLER_68_648 VGND VGND VPWR VPWR sky130_fd_sc_hd__decap_3
XFILLER_68_80 VGND VGND VPWR VPWR sky130_fd_sc_hd__decap_3
XFILLER_67_125 VGND VGND VPWR VPWR sky130_fd_sc_hd__decap_3
XFILLER_68_91 VGND VGND VPWR VPWR sky130_fd_sc_hd__decap_3
XFILLER_83_607 VGND VGND VPWR VPWR sky130_fd_sc_hd__decap_3
X_4090_ _7302_/Q _4417_/A2 _4088_/X _4089_/X VGND VGND VPWR VPWR _4090_/X sky130_fd_sc_hd__a211o_2
XFILLER_55_309 VGND VGND VPWR VPWR sky130_fd_sc_hd__decap_3
XFILLER_83_629 VGND VGND VPWR VPWR sky130_fd_sc_hd__decap_3
XFILLER_48_383 VGND VGND VPWR VPWR sky130_fd_sc_hd__decap_3
XFILLER_76_681 VGND VGND VPWR VPWR sky130_fd_sc_hd__decap_3
XFILLER_82_128 VGND VGND VPWR VPWR sky130_fd_sc_hd__fill_1
XFILLER_82_139 VGND VGND VPWR VPWR sky130_fd_sc_hd__fill_1
XFILLER_36_578 VGND VGND VPWR VPWR sky130_fd_sc_hd__fill_1
XFILLER_63_364 VGND VGND VPWR VPWR sky130_fd_sc_hd__decap_3
XFILLER_90_150 VGND VGND VPWR VPWR sky130_fd_sc_hd__decap_3
XFILLER_91_662 VGND VGND VPWR VPWR sky130_fd_sc_hd__decap_3
XFILLER_91_673 VGND VGND VPWR VPWR sky130_fd_sc_hd__decap_3
Xplace331 _4195_/A2 VGND VGND VPWR VPWR _4434_/B1 sky130_fd_sc_hd__buf_2
Xplace320 _4356_/A2 VGND VGND VPWR VPWR _4418_/A2 sky130_fd_sc_hd__buf_2
X_6800_ _7386_/CLK _6800_/D VGND VGND VPWR VPWR _6800_/Q sky130_fd_sc_hd__dfxtp_2
XFILLER_23_228 VGND VGND VPWR VPWR sky130_fd_sc_hd__fill_1
XFILLER_63_386 VGND VGND VPWR VPWR sky130_fd_sc_hd__decap_3
Xplace364 _4305_/B VGND VGND VPWR VPWR _4265_/B sky130_fd_sc_hd__buf_2
Xplace353 _4946_/S VGND VGND VPWR VPWR _5028_/S sky130_fd_sc_hd__buf_2
Xplace342 _5072_/A VGND VGND VPWR VPWR _3526_/B sky130_fd_sc_hd__buf_2
X_4992_ _4987_/A _4991_/Y _5020_/A VGND VGND VPWR VPWR _4992_/Y sky130_fd_sc_hd__a21oi_2
XFILLER_16_291 VGND VGND VPWR VPWR sky130_fd_sc_hd__decap_3
XFILLER_51_559 VGND VGND VPWR VPWR sky130_fd_sc_hd__fill_1
Xplace386 _5221_/B VGND VGND VPWR VPWR _5205_/B sky130_fd_sc_hd__buf_2
Xplace397 _3560_/Y VGND VGND VPWR VPWR _3562_/B sky130_fd_sc_hd__buf_2
Xplace375 _3469_/A VGND VGND VPWR VPWR _4799_/A sky130_fd_sc_hd__buf_2
X_6731_ _6965_/CLK _6731_/D VGND VGND VPWR VPWR _6731_/Q sky130_fd_sc_hd__dfxtp_2
X_3943_ _7368_/Q _4486_/A0 _3958_/S VGND VGND VPWR VPWR _7368_/D sky130_fd_sc_hd__mux2_2
X_6662_ _6686_/A VGND VGND VPWR VPWR _6662_/Y sky130_fd_sc_hd__inv_2
X_3874_ _5104_/A _3874_/B VGND VGND VPWR VPWR _3874_/X sky130_fd_sc_hd__or2_2
Xclkbuf_3_2__f_clk clkbuf_0_clk/X VGND VGND VPWR VPWR clkbuf_3_2__f_clk/X sky130_fd_sc_hd__clkbuf_16
X_5613_ _5613_/A _5622_/B VGND VGND VPWR VPWR _7021_/D sky130_fd_sc_hd__or2_2
X_6593_ _6635_/A VGND VGND VPWR VPWR _6593_/Y sky130_fd_sc_hd__inv_2
XFILLER_105_528 VGND VGND VPWR VPWR sky130_fd_sc_hd__decap_3
X_7214_ _7374_/CLK _7214_/D _6494_/Y VGND VGND VPWR VPWR _7214_/Q sky130_fd_sc_hd__dfrtp_2
X_4426_ _4446_/A _4426_/B VGND VGND VPWR VPWR _4813_/A sky130_fd_sc_hd__or2_2
XFILLER_113_550 VGND VGND VPWR VPWR sky130_fd_sc_hd__decap_3
X_7145_ _7402_/CLK _7145_/D _6425_/Y VGND VGND VPWR VPWR _7145_/Q sky130_fd_sc_hd__dfrtp_2
XFILLER_100_200 VGND VGND VPWR VPWR sky130_fd_sc_hd__decap_3
XFILLER_113_561 VGND VGND VPWR VPWR sky130_fd_sc_hd__decap_3
XFILLER_58_103 VGND VGND VPWR VPWR sky130_fd_sc_hd__decap_3
XFILLER_59_626 VGND VGND VPWR VPWR sky130_fd_sc_hd__decap_3
XFILLER_86_401 VGND VGND VPWR VPWR sky130_fd_sc_hd__decap_3
X_4357_ _4352_/X _4356_/X _4327_/A VGND VGND VPWR VPWR _4367_/C sky130_fd_sc_hd__o21ai_2
XFILLER_98_272 VGND VGND VPWR VPWR sky130_fd_sc_hd__decap_3
XFILLER_100_244 VGND VGND VPWR VPWR sky130_fd_sc_hd__decap_3
XFILLER_113_594 VGND VGND VPWR VPWR sky130_fd_sc_hd__decap_3
XFILLER_58_147 VGND VGND VPWR VPWR sky130_fd_sc_hd__decap_3
XFILLER_59_659 VGND VGND VPWR VPWR sky130_fd_sc_hd__decap_3
XFILLER_74_607 VGND VGND VPWR VPWR sky130_fd_sc_hd__decap_3
X_7076_ _7265_/CLK _7076_/D _6356_/Y VGND VGND VPWR VPWR _7076_/Q sky130_fd_sc_hd__dfrtp_2
X_4288_ _4394_/A _4337_/B _4288_/C _4288_/D VGND VGND VPWR VPWR _4288_/X sky130_fd_sc_hd__or4_4
X_3308_ _3327_/A _3362_/A VGND VGND VPWR VPWR _5118_/C sky130_fd_sc_hd__nand2_2
XFILLER_104_12 VGND VGND VPWR VPWR sky130_fd_sc_hd__decap_3
XFILLER_39_361 VGND VGND VPWR VPWR sky130_fd_sc_hd__fill_2
XFILLER_46_309 VGND VGND VPWR VPWR sky130_fd_sc_hd__decap_3
XFILLER_100_288 VGND VGND VPWR VPWR sky130_fd_sc_hd__decap_3
XFILLER_27_534 VGND VGND VPWR VPWR sky130_fd_sc_hd__decap_3
XFILLER_64_27 VGND VGND VPWR VPWR sky130_fd_sc_hd__fill_1
XFILLER_66_180 VGND VGND VPWR VPWR sky130_fd_sc_hd__decap_3
XFILLER_73_139 VGND VGND VPWR VPWR sky130_fd_sc_hd__decap_3
XFILLER_27_556 VGND VGND VPWR VPWR sky130_fd_sc_hd__decap_3
XFILLER_54_353 VGND VGND VPWR VPWR sky130_fd_sc_hd__decap_3
XFILLER_64_49 VGND VGND VPWR VPWR sky130_fd_sc_hd__decap_3
XFILLER_82_640 VGND VGND VPWR VPWR sky130_fd_sc_hd__decap_3
XFILLER_82_651 VGND VGND VPWR VPWR sky130_fd_sc_hd__decap_3
XFILLER_54_386 VGND VGND VPWR VPWR sky130_fd_sc_hd__decap_3
XFILLER_82_684 VGND VGND VPWR VPWR sky130_fd_sc_hd__decap_3
XTAP_TAPCELL_ROW_64_1018 VGND VPWR sky130_fd_sc_hd__tapvpwrvgnd_1
XFILLER_14_239 VGND VGND VPWR VPWR sky130_fd_sc_hd__decap_3
Xfanout21 _6632_/A VGND VGND VPWR VPWR _6599_/A sky130_fd_sc_hd__buf_2
X_6929_ _6972_/CLK _6929_/D VGND VGND VPWR VPWR _6929_/Q sky130_fd_sc_hd__dfxtp_2
XFILLER_22_261 VGND VGND VPWR VPWR sky130_fd_sc_hd__decap_3
XFILLER_80_15 VGND VGND VPWR VPWR sky130_fd_sc_hd__decap_3
Xfanout32 _6576_/A VGND VGND VPWR VPWR _6604_/A sky130_fd_sc_hd__buf_2
Xfanout43 fanout51/X VGND VGND VPWR VPWR _6547_/A sky130_fd_sc_hd__clkdlybuf4s25_1
Xfanout54 _6674_/A VGND VGND VPWR VPWR _6670_/A sky130_fd_sc_hd__clkdlybuf4s25_1
Xfanout65 _6619_/A VGND VGND VPWR VPWR _6647_/A sky130_fd_sc_hd__buf_2
XTAP_TAPCELL_ROW_40_727 VGND VPWR sky130_fd_sc_hd__tapvpwrvgnd_1
XFILLER_13_20 VGND VGND VPWR VPWR sky130_fd_sc_hd__decap_3
XFILLER_22_294 VGND VGND VPWR VPWR sky130_fd_sc_hd__decap_3
XFILLER_80_59 VGND VGND VPWR VPWR sky130_fd_sc_hd__decap_3
XFILLER_13_53 VGND VGND VPWR VPWR sky130_fd_sc_hd__decap_3
XFILLER_13_75 VGND VGND VPWR VPWR sky130_fd_sc_hd__decap_3
XFILLER_6_405 VGND VGND VPWR VPWR sky130_fd_sc_hd__decap_3
XFILLER_6_427 VGND VGND VPWR VPWR sky130_fd_sc_hd__decap_3
XFILLER_89_57 VGND VGND VPWR VPWR sky130_fd_sc_hd__decap_3
XTAP_TAPCELL_ROW_20_495 VGND VPWR sky130_fd_sc_hd__tapvpwrvgnd_1
XFILLER_2_633 VGND VGND VPWR VPWR sky130_fd_sc_hd__decap_3
XTAP_TAPCELL_ROW_75_1147 VGND VPWR sky130_fd_sc_hd__tapvpwrvgnd_1
XFILLER_1_143 VGND VGND VPWR VPWR sky130_fd_sc_hd__decap_3
XFILLER_2_666 VGND VGND VPWR VPWR sky130_fd_sc_hd__decap_3
XFILLER_49_147 VGND VGND VPWR VPWR sky130_fd_sc_hd__decap_3
XFILLER_89_294 VGND VGND VPWR VPWR sky130_fd_sc_hd__decap_3
XFILLER_49_169 VGND VGND VPWR VPWR sky130_fd_sc_hd__decap_3
XFILLER_65_629 VGND VGND VPWR VPWR sky130_fd_sc_hd__decap_3
XFILLER_77_489 VGND VGND VPWR VPWR sky130_fd_sc_hd__decap_3
XFILLER_92_404 VGND VGND VPWR VPWR sky130_fd_sc_hd__decap_3
XTAP_TAPCELL_ROW_48_827 VGND VPWR sky130_fd_sc_hd__tapvpwrvgnd_1
XFILLER_45_320 VGND VGND VPWR VPWR sky130_fd_sc_hd__decap_3
XFILLER_58_681 VGND VGND VPWR VPWR sky130_fd_sc_hd__decap_3
XFILLER_64_139 VGND VGND VPWR VPWR sky130_fd_sc_hd__fill_1
XFILLER_92_448 VGND VGND VPWR VPWR sky130_fd_sc_hd__decap_3
XFILLER_18_545 VGND VGND VPWR VPWR sky130_fd_sc_hd__fill_2
XFILLER_45_331 VGND VGND VPWR VPWR sky130_fd_sc_hd__decap_3
XFILLER_73_662 VGND VGND VPWR VPWR sky130_fd_sc_hd__decap_3
Xhold1190 _7225_/Q VGND VGND VPWR VPWR _5207_/A sky130_fd_sc_hd__dlygate4sd3_1
XFILLER_33_515 VGND VGND VPWR VPWR sky130_fd_sc_hd__fill_1
XFILLER_60_312 VGND VGND VPWR VPWR sky130_fd_sc_hd__fill_1
XFILLER_73_673 VGND VGND VPWR VPWR sky130_fd_sc_hd__decap_3
XTAP_TAPCELL_ROW_86_1287 VGND VPWR sky130_fd_sc_hd__tapvpwrvgnd_1
XTAP_TAPCELL_ROW_28_584 VGND VPWR sky130_fd_sc_hd__tapvpwrvgnd_1
XFILLER_33_559 VGND VGND VPWR VPWR sky130_fd_sc_hd__fill_1
XFILLER_54_71 VGND VGND VPWR VPWR sky130_fd_sc_hd__decap_3
XFILLER_72_183 VGND VGND VPWR VPWR sky130_fd_sc_hd__decap_3
XFILLER_41_570 VGND VGND VPWR VPWR sky130_fd_sc_hd__fill_1
XFILLER_70_70 VGND VGND VPWR VPWR sky130_fd_sc_hd__decap_3
Xclkload13 _6909_/CLK VGND VGND VPWR VPWR clkload13/X sky130_fd_sc_hd__clkbuf_8
Xclkload24 _7363_/CLK VGND VGND VPWR VPWR clkload24/X sky130_fd_sc_hd__clkbuf_8
Xclkload35 _7372_/CLK VGND VGND VPWR VPWR clkload35/X sky130_fd_sc_hd__clkbuf_8
X_3590_ _3590_/A _3590_/B _3590_/C VGND VGND VPWR VPWR _3620_/C sky130_fd_sc_hd__and3_2
XFILLER_114_336 VGND VGND VPWR VPWR sky130_fd_sc_hd__decap_3
X_5260_ _5260_/A0 _4964_/X _5274_/S VGND VGND VPWR VPWR _7200_/D sky130_fd_sc_hd__mux2_2
XFILLER_114_369 VGND VGND VPWR VPWR sky130_fd_sc_hd__fill_2
XFILLER_48_3 VGND VGND VPWR VPWR sky130_fd_sc_hd__decap_3
XFILLER_79_90 VGND VGND VPWR VPWR sky130_fd_sc_hd__decap_3
X_4211_ _4633_/A _4143_/X _4206_/X _4384_/A _4210_/X VGND VGND VPWR VPWR _4778_/A
+ sky130_fd_sc_hd__a221oi_2
XFILLER_110_531 VGND VGND VPWR VPWR sky130_fd_sc_hd__fill_1
XFILLER_110_542 VGND VGND VPWR VPWR sky130_fd_sc_hd__decap_3
XFILLER_95_220 VGND VGND VPWR VPWR sky130_fd_sc_hd__decap_3
XFILLER_95_231 VGND VGND VPWR VPWR sky130_fd_sc_hd__decap_3
X_4142_ _4205_/A _4142_/B _4142_/C VGND VGND VPWR VPWR _4142_/X sky130_fd_sc_hd__and3_2
XFILLER_110_575 VGND VGND VPWR VPWR sky130_fd_sc_hd__decap_3
XFILLER_56_607 VGND VGND VPWR VPWR sky130_fd_sc_hd__decap_3
XFILLER_95_264 VGND VGND VPWR VPWR sky130_fd_sc_hd__decap_3
X_4073_ _7275_/Q _4437_/A2 _4070_/X _4072_/X VGND VGND VPWR VPWR _4073_/X sky130_fd_sc_hd__a211o_2
XFILLER_36_320 VGND VGND VPWR VPWR sky130_fd_sc_hd__decap_3
XFILLER_48_180 VGND VGND VPWR VPWR sky130_fd_sc_hd__decap_3
XFILLER_55_139 VGND VGND VPWR VPWR sky130_fd_sc_hd__decap_3
XFILLER_95_297 VGND VGND VPWR VPWR sky130_fd_sc_hd__decap_3
XFILLER_64_640 VGND VGND VPWR VPWR sky130_fd_sc_hd__decap_3
XFILLER_64_651 VGND VGND VPWR VPWR sky130_fd_sc_hd__decap_3
XFILLER_24_515 VGND VGND VPWR VPWR sky130_fd_sc_hd__decap_3
XFILLER_63_161 VGND VGND VPWR VPWR sky130_fd_sc_hd__decap_3
XFILLER_64_684 VGND VGND VPWR VPWR sky130_fd_sc_hd__decap_3
XFILLER_70_109 VGND VGND VPWR VPWR sky130_fd_sc_hd__decap_3
XFILLER_51_334 VGND VGND VPWR VPWR sky130_fd_sc_hd__fill_2
XFILLER_63_183 VGND VGND VPWR VPWR sky130_fd_sc_hd__fill_1
X_4975_ _4983_/A _4975_/B VGND VGND VPWR VPWR _4975_/Y sky130_fd_sc_hd__nand2_2
XFILLER_11_209 VGND VGND VPWR VPWR sky130_fd_sc_hd__decap_3
X_6714_ _7405_/CLK _6714_/D VGND VGND VPWR VPWR _6714_/Q sky130_fd_sc_hd__dfxtp_2
X_3926_ _6913_/Q _3926_/A2 _3926_/B1 _6777_/Q _3925_/X VGND VGND VPWR VPWR _3926_/X
+ sky130_fd_sc_hd__a221o_2
XFILLER_32_592 VGND VGND VPWR VPWR sky130_fd_sc_hd__fill_2
XFILLER_109_108 VGND VGND VPWR VPWR sky130_fd_sc_hd__decap_3
XFILLER_109_119 VGND VGND VPWR VPWR sky130_fd_sc_hd__decap_3
XFILLER_50_18 VGND VGND VPWR VPWR sky130_fd_sc_hd__decap_3
Xclkload7 clkload7/A VGND VGND VPWR VPWR clkload7/X sky130_fd_sc_hd__clkbuf_16
X_6645_ _6675_/A VGND VGND VPWR VPWR _6645_/Y sky130_fd_sc_hd__inv_2
X_3857_ hold971/X _4466_/A _3856_/X VGND VGND VPWR VPWR _7387_/D sky130_fd_sc_hd__a21o_2
X_6576_ _6576_/A VGND VGND VPWR VPWR _6576_/Y sky130_fd_sc_hd__inv_2
X_3788_ _3741_/X _3785_/X _3787_/X _3735_/X VGND VGND VPWR VPWR _3788_/X sky130_fd_sc_hd__a22o_2
XFILLER_3_408 VGND VGND VPWR VPWR sky130_fd_sc_hd__decap_3
XFILLER_78_209 VGND VGND VPWR VPWR sky130_fd_sc_hd__fill_1
Xoutput551 _6984_/Q VGND VGND VPWR VPWR pc_out[7] sky130_fd_sc_hd__clkdlybuf4s25_1
Xoutput540 _7003_/Q VGND VGND VPWR VPWR pc_out[26] sky130_fd_sc_hd__clkdlybuf4s25_1
XFILLER_115_11 VGND VGND VPWR VPWR sky130_fd_sc_hd__decap_3
X_4409_ _4425_/A _4409_/B VGND VGND VPWR VPWR _4411_/B sky130_fd_sc_hd__nand2_2
XFILLER_113_380 VGND VGND VPWR VPWR sky130_fd_sc_hd__decap_3
XFILLER_115_44 VGND VGND VPWR VPWR sky130_fd_sc_hd__decap_3
XFILLER_86_231 VGND VGND VPWR VPWR sky130_fd_sc_hd__decap_3
X_7128_ clkload5/A _7128_/D _6408_/Y VGND VGND VPWR VPWR _7128_/Q sky130_fd_sc_hd__dfrtp_2
XFILLER_99_592 VGND VGND VPWR VPWR sky130_fd_sc_hd__fill_1
XFILLER_115_66 VGND VGND VPWR VPWR sky130_fd_sc_hd__decap_3
XFILLER_47_607 VGND VGND VPWR VPWR sky130_fd_sc_hd__decap_3
XFILLER_47_629 VGND VGND VPWR VPWR sky130_fd_sc_hd__decap_3
XFILLER_75_15 VGND VGND VPWR VPWR sky130_fd_sc_hd__decap_3
XFILLER_75_26 VGND VGND VPWR VPWR sky130_fd_sc_hd__decap_3
XFILLER_86_253 VGND VGND VPWR VPWR sky130_fd_sc_hd__decap_3
X_7059_ clkload6/A _7059_/D _6339_/Y VGND VGND VPWR VPWR _7059_/Q sky130_fd_sc_hd__dfrtp_2
XTAP_TAPCELL_ROW_70_1088 VGND VPWR sky130_fd_sc_hd__tapvpwrvgnd_1
XFILLER_115_99 VGND VGND VPWR VPWR sky130_fd_sc_hd__decap_3
XFILLER_74_437 VGND VGND VPWR VPWR sky130_fd_sc_hd__decap_3
XFILLER_86_286 VGND VGND VPWR VPWR sky130_fd_sc_hd__decap_3
XFILLER_39_191 VGND VGND VPWR VPWR sky130_fd_sc_hd__decap_3
XFILLER_55_662 VGND VGND VPWR VPWR sky130_fd_sc_hd__decap_3
XFILLER_74_459 VGND VGND VPWR VPWR sky130_fd_sc_hd__decap_3
XFILLER_54_150 VGND VGND VPWR VPWR sky130_fd_sc_hd__decap_3
XFILLER_55_673 VGND VGND VPWR VPWR sky130_fd_sc_hd__decap_3
XFILLER_61_109 VGND VGND VPWR VPWR sky130_fd_sc_hd__decap_3
XFILLER_70_610 VGND VGND VPWR VPWR sky130_fd_sc_hd__decap_3
XFILLER_54_183 VGND VGND VPWR VPWR sky130_fd_sc_hd__fill_2
XFILLER_70_643 VGND VGND VPWR VPWR sky130_fd_sc_hd__fill_1
XFILLER_70_654 VGND VGND VPWR VPWR sky130_fd_sc_hd__decap_3
XFILLER_42_356 VGND VGND VPWR VPWR sky130_fd_sc_hd__decap_3
XFILLER_70_687 VGND VGND VPWR VPWR sky130_fd_sc_hd__decap_3
XFILLER_91_69 VGND VGND VPWR VPWR sky130_fd_sc_hd__decap_3
XTAP_TAPCELL_ROW_53_885 VGND VPWR sky130_fd_sc_hd__tapvpwrvgnd_1
XTAP_TAPCELL_ROW_25_554 VGND VPWR sky130_fd_sc_hd__tapvpwrvgnd_1
XFILLER_23_570 VGND VGND VPWR VPWR sky130_fd_sc_hd__fill_2
XFILLER_24_85 VGND VGND VPWR VPWR sky130_fd_sc_hd__decap_3
XFILLER_10_253 VGND VGND VPWR VPWR sky130_fd_sc_hd__decap_3
XFILLER_109_620 VGND VGND VPWR VPWR sky130_fd_sc_hd__decap_3
XFILLER_108_130 VGND VGND VPWR VPWR sky130_fd_sc_hd__decap_3
XFILLER_108_141 VGND VGND VPWR VPWR sky130_fd_sc_hd__decap_3
XFILLER_109_653 VGND VGND VPWR VPWR sky130_fd_sc_hd__decap_3
XFILLER_2_430 VGND VGND VPWR VPWR sky130_fd_sc_hd__decap_3
XFILLER_2_463 VGND VGND VPWR VPWR sky130_fd_sc_hd__decap_3
XFILLER_34_9 VGND VGND VPWR VPWR sky130_fd_sc_hd__decap_3
XFILLER_77_231 VGND VGND VPWR VPWR sky130_fd_sc_hd__fill_1
XFILLER_1_23 VGND VGND VPWR VPWR sky130_fd_sc_hd__decap_3
XTAP_TAPCELL_ROW_88_1305 VGND VPWR sky130_fd_sc_hd__tapvpwrvgnd_1
XFILLER_77_275 VGND VGND VPWR VPWR sky130_fd_sc_hd__decap_3
XFILLER_1_78 VGND VGND VPWR VPWR sky130_fd_sc_hd__decap_3
XFILLER_46_651 VGND VGND VPWR VPWR sky130_fd_sc_hd__decap_3
XFILLER_45_172 VGND VGND VPWR VPWR sky130_fd_sc_hd__decap_3
XFILLER_46_684 VGND VGND VPWR VPWR sky130_fd_sc_hd__decap_3
XFILLER_65_81 VGND VGND VPWR VPWR sky130_fd_sc_hd__decap_3
XFILLER_33_323 VGND VGND VPWR VPWR sky130_fd_sc_hd__decap_3
XFILLER_60_120 VGND VGND VPWR VPWR sky130_fd_sc_hd__fill_1
XFILLER_61_632 VGND VGND VPWR VPWR sky130_fd_sc_hd__decap_3
XFILLER_73_492 VGND VGND VPWR VPWR sky130_fd_sc_hd__decap_3
XFILLER_61_665 VGND VGND VPWR VPWR sky130_fd_sc_hd__decap_3
XFILLER_61_676 VGND VGND VPWR VPWR sky130_fd_sc_hd__decap_3
XFILLER_14_581 VGND VGND VPWR VPWR sky130_fd_sc_hd__decap_3
XFILLER_14_592 VGND VGND VPWR VPWR sky130_fd_sc_hd__fill_2
XFILLER_60_197 VGND VGND VPWR VPWR sky130_fd_sc_hd__decap_3
X_4760_ _4983_/A _4760_/B VGND VGND VPWR VPWR _4760_/Y sky130_fd_sc_hd__nand2_2
X_4691_ _7004_/Q _4665_/X _4804_/A _4757_/A VGND VGND VPWR VPWR _4749_/B sky130_fd_sc_hd__a31o_2
X_3711_ _3746_/A VGND VGND VPWR VPWR _3735_/A sky130_fd_sc_hd__inv_2
XTAP_TAPCELL_ROW_99_1445 VGND VPWR sky130_fd_sc_hd__tapvpwrvgnd_1
XTAP_TAPCELL_ROW_99_1434 VGND VPWR sky130_fd_sc_hd__tapvpwrvgnd_1
XPHY_EDGE_ROW_112_Right_112 VGND VGND VPWR VPWR sky130_fd_sc_hd__decap_3
X_6430_ _6652_/A VGND VGND VPWR VPWR _6430_/Y sky130_fd_sc_hd__inv_2
X_3642_ _6718_/Q _6808_/Q _6896_/Q _6944_/Q _3991_/B _3665_/B VGND VGND VPWR VPWR
+ _3642_/X sky130_fd_sc_hd__mux4_2
X_6361_ _6385_/A VGND VGND VPWR VPWR _6361_/Y sky130_fd_sc_hd__inv_2
XFILLER_114_100 VGND VGND VPWR VPWR sky130_fd_sc_hd__decap_3
XFILLER_115_612 VGND VGND VPWR VPWR sky130_fd_sc_hd__decap_3
XFILLER_115_623 VGND VGND VPWR VPWR sky130_fd_sc_hd__decap_3
X_5312_ _5312_/A0 _4864_/X _5315_/S VGND VGND VPWR VPWR _7174_/D sky130_fd_sc_hd__mux2_2
X_3573_ _7316_/Q _3989_/S _4528_/B _7284_/Q VGND VGND VPWR VPWR _3573_/X sky130_fd_sc_hd__a22o_2
XPHY_EDGE_ROW_49_Right_49 VGND VGND VPWR VPWR sky130_fd_sc_hd__decap_3
XFILLER_114_133 VGND VGND VPWR VPWR sky130_fd_sc_hd__decap_3
XFILLER_114_144 VGND VGND VPWR VPWR sky130_fd_sc_hd__decap_3
XFILLER_115_656 VGND VGND VPWR VPWR sky130_fd_sc_hd__decap_3
XFILLER_5_290 VGND VGND VPWR VPWR sky130_fd_sc_hd__decap_3
X_6292_ _6637_/A VGND VGND VPWR VPWR _6292_/Y sky130_fd_sc_hd__inv_2
XFILLER_114_177 VGND VGND VPWR VPWR sky130_fd_sc_hd__decap_3
X_5243_ _5243_/A0 _4822_/X _5262_/S VGND VGND VPWR VPWR _7208_/D sky130_fd_sc_hd__mux2_2
XFILLER_102_339 VGND VGND VPWR VPWR sky130_fd_sc_hd__decap_3
XFILLER_68_220 VGND VGND VPWR VPWR sky130_fd_sc_hd__decap_3
XFILLER_110_350 VGND VGND VPWR VPWR sky130_fd_sc_hd__decap_3
XFILLER_29_629 VGND VGND VPWR VPWR sky130_fd_sc_hd__fill_1
XFILLER_68_242 VGND VGND VPWR VPWR sky130_fd_sc_hd__decap_3
XFILLER_68_253 VGND VGND VPWR VPWR sky130_fd_sc_hd__fill_1
XFILLER_96_551 VGND VGND VPWR VPWR sky130_fd_sc_hd__decap_3
X_4125_ _4205_/A _4117_/B _4117_/C _4124_/B VGND VGND VPWR VPWR _4125_/X sky130_fd_sc_hd__a31o_2
XFILLER_28_128 VGND VGND VPWR VPWR sky130_fd_sc_hd__decap_3
XFILLER_83_212 VGND VGND VPWR VPWR sky130_fd_sc_hd__fill_1
XFILLER_96_584 VGND VGND VPWR VPWR sky130_fd_sc_hd__decap_3
XFILLER_37_651 VGND VGND VPWR VPWR sky130_fd_sc_hd__fill_1
XFILLER_45_18 VGND VGND VPWR VPWR sky130_fd_sc_hd__fill_1
X_4056_ _7340_/Q _3935_/S _5229_/C _7148_/Q VGND VGND VPWR VPWR _4056_/X sky130_fd_sc_hd__a22o_2
XPHY_EDGE_ROW_58_Right_58 VGND VGND VPWR VPWR sky130_fd_sc_hd__decap_3
XFILLER_36_161 VGND VGND VPWR VPWR sky130_fd_sc_hd__decap_3
XFILLER_37_673 VGND VGND VPWR VPWR sky130_fd_sc_hd__decap_3
XFILLER_52_610 VGND VGND VPWR VPWR sky130_fd_sc_hd__decap_3
XTAP_TAPCELL_ROW_108_1552 VGND VPWR sky130_fd_sc_hd__tapvpwrvgnd_1
XFILLER_52_643 VGND VGND VPWR VPWR sky130_fd_sc_hd__fill_1
XFILLER_52_654 VGND VGND VPWR VPWR sky130_fd_sc_hd__decap_3
XFILLER_51_164 VGND VGND VPWR VPWR sky130_fd_sc_hd__decap_3
XFILLER_52_687 VGND VGND VPWR VPWR sky130_fd_sc_hd__decap_3
XFILLER_101_68 VGND VGND VPWR VPWR sky130_fd_sc_hd__decap_3
XFILLER_51_175 VGND VGND VPWR VPWR sky130_fd_sc_hd__decap_3
XFILLER_51_197 VGND VGND VPWR VPWR sky130_fd_sc_hd__decap_3
X_4958_ _4983_/B VGND VGND VPWR VPWR _4958_/Y sky130_fd_sc_hd__inv_2
XTAP_TAPCELL_ROW_22_513 VGND VPWR sky130_fd_sc_hd__tapvpwrvgnd_1
X_4889_ _4890_/B _4889_/B VGND VGND VPWR VPWR _4889_/Y sky130_fd_sc_hd__xnor2_2
X_3909_ hold962/X _5104_/A _3908_/X VGND VGND VPWR VPWR _7379_/D sky130_fd_sc_hd__a21o_2
XTAP_TAPCELL_ROW_50_855 VGND VPWR sky130_fd_sc_hd__tapvpwrvgnd_1
X_6628_ _6635_/A VGND VGND VPWR VPWR _6628_/Y sky130_fd_sc_hd__inv_2
XPHY_EDGE_ROW_67_Right_67 VGND VGND VPWR VPWR sky130_fd_sc_hd__decap_3
XFILLER_106_612 VGND VGND VPWR VPWR sky130_fd_sc_hd__decap_3
XFILLER_10_21 VGND VGND VPWR VPWR sky130_fd_sc_hd__decap_3
XFILLER_3_205 VGND VGND VPWR VPWR sky130_fd_sc_hd__decap_3
XFILLER_3_216 VGND VGND VPWR VPWR sky130_fd_sc_hd__decap_3
X_6559_ _6637_/A VGND VGND VPWR VPWR _6559_/Y sky130_fd_sc_hd__inv_2
XFILLER_106_645 VGND VGND VPWR VPWR sky130_fd_sc_hd__decap_3
XFILLER_10_32 VGND VGND VPWR VPWR sky130_fd_sc_hd__decap_3
XFILLER_106_678 VGND VGND VPWR VPWR sky130_fd_sc_hd__decap_3
XFILLER_10_65 VGND VGND VPWR VPWR sky130_fd_sc_hd__decap_3
XTAP_TAPCELL_ROW_72_1117 VGND VPWR sky130_fd_sc_hd__tapvpwrvgnd_1
XFILLER_105_199 VGND VGND VPWR VPWR sky130_fd_sc_hd__decap_3
XFILLER_101_361 VGND VGND VPWR VPWR sky130_fd_sc_hd__decap_3
XFILLER_19_41 VGND VGND VPWR VPWR sky130_fd_sc_hd__decap_3
XFILLER_19_63 VGND VGND VPWR VPWR sky130_fd_sc_hd__fill_1
XFILLER_59_297 VGND VGND VPWR VPWR sky130_fd_sc_hd__decap_3
XFILLER_74_212 VGND VGND VPWR VPWR sky130_fd_sc_hd__decap_3
XFILLER_74_223 VGND VGND VPWR VPWR sky130_fd_sc_hd__decap_3
XPHY_EDGE_ROW_76_Right_76 VGND VGND VPWR VPWR sky130_fd_sc_hd__decap_3
XFILLER_19_139 VGND VGND VPWR VPWR sky130_fd_sc_hd__decap_3
XFILLER_28_651 VGND VGND VPWR VPWR sky130_fd_sc_hd__fill_1
XFILLER_74_245 VGND VGND VPWR VPWR sky130_fd_sc_hd__decap_3
XTAP_TAPCELL_ROW_58_944 VGND VPWR sky130_fd_sc_hd__tapvpwrvgnd_1
XFILLER_34_109 VGND VGND VPWR VPWR sky130_fd_sc_hd__decap_3
XFILLER_62_429 VGND VGND VPWR VPWR sky130_fd_sc_hd__decap_3
XTAP_TAPCELL_ROW_2_271 VGND VPWR sky130_fd_sc_hd__tapvpwrvgnd_1
XFILLER_15_323 VGND VGND VPWR VPWR sky130_fd_sc_hd__decap_3
XFILLER_35_40 VGND VGND VPWR VPWR sky130_fd_sc_hd__decap_3
XFILLER_15_356 VGND VGND VPWR VPWR sky130_fd_sc_hd__decap_3
XFILLER_30_304 VGND VGND VPWR VPWR sky130_fd_sc_hd__decap_3
XFILLER_42_153 VGND VGND VPWR VPWR sky130_fd_sc_hd__decap_3
XFILLER_43_676 VGND VGND VPWR VPWR sky130_fd_sc_hd__decap_3
XFILLER_70_451 VGND VGND VPWR VPWR sky130_fd_sc_hd__fill_1
XFILLER_70_462 VGND VGND VPWR VPWR sky130_fd_sc_hd__decap_3
XTAP_TAPCELL_ROW_83_1246 VGND VPWR sky130_fd_sc_hd__tapvpwrvgnd_1
XFILLER_30_315 VGND VGND VPWR VPWR sky130_fd_sc_hd__decap_3
XFILLER_35_95 VGND VGND VPWR VPWR sky130_fd_sc_hd__fill_2
XFILLER_42_197 VGND VGND VPWR VPWR sky130_fd_sc_hd__decap_3
XFILLER_70_495 VGND VGND VPWR VPWR sky130_fd_sc_hd__decap_3
XFILLER_51_72 VGND VGND VPWR VPWR sky130_fd_sc_hd__decap_3
XFILLER_7_522 VGND VGND VPWR VPWR sky130_fd_sc_hd__decap_3
XPHY_EDGE_ROW_85_Right_85 VGND VGND VPWR VPWR sky130_fd_sc_hd__decap_3
XFILLER_51_94 VGND VGND VPWR VPWR sky130_fd_sc_hd__decap_3
XFILLER_7_544 VGND VGND VPWR VPWR sky130_fd_sc_hd__decap_3
XTAP_TAPCELL_ROW_94_1375 VGND VPWR sky130_fd_sc_hd__tapvpwrvgnd_1
XFILLER_112_604 VGND VGND VPWR VPWR sky130_fd_sc_hd__decap_3
XFILLER_111_125 VGND VGND VPWR VPWR sky130_fd_sc_hd__decap_3
XFILLER_112_637 VGND VGND VPWR VPWR sky130_fd_sc_hd__decap_3
XFILLER_112_648 VGND VGND VPWR VPWR sky130_fd_sc_hd__decap_3
XFILLER_32_6 VGND VGND VPWR VPWR sky130_fd_sc_hd__decap_3
XFILLER_97_326 VGND VGND VPWR VPWR sky130_fd_sc_hd__decap_3
XPHY_EDGE_ROW_29_Left_146 VGND VGND VPWR VPWR sky130_fd_sc_hd__decap_3
XFILLER_111_158 VGND VGND VPWR VPWR sky130_fd_sc_hd__decap_3
XFILLER_111_169 VGND VGND VPWR VPWR sky130_fd_sc_hd__decap_3
XPHY_EDGE_ROW_94_Right_94 VGND VGND VPWR VPWR sky130_fd_sc_hd__decap_3
XFILLER_78_584 VGND VGND VPWR VPWR sky130_fd_sc_hd__decap_3
XFILLER_65_256 VGND VGND VPWR VPWR sky130_fd_sc_hd__fill_2
XFILLER_76_80 VGND VGND VPWR VPWR sky130_fd_sc_hd__decap_3
XFILLER_19_662 VGND VGND VPWR VPWR sky130_fd_sc_hd__fill_2
XFILLER_80_215 VGND VGND VPWR VPWR sky130_fd_sc_hd__fill_1
XFILLER_33_164 VGND VGND VPWR VPWR sky130_fd_sc_hd__decap_3
X_4812_ _4827_/A _4827_/B VGND VGND VPWR VPWR _4812_/Y sky130_fd_sc_hd__nor2_2
XPHY_EDGE_ROW_38_Left_155 VGND VGND VPWR VPWR sky130_fd_sc_hd__decap_3
X_4743_ _4069_/Y _4081_/X _4741_/X _4742_/Y VGND VGND VPWR VPWR _4743_/X sky130_fd_sc_hd__a31o_2
XTAP_TAPCELL_ROW_103_1493 VGND VPWR sky130_fd_sc_hd__tapvpwrvgnd_1
XTAP_TAPCELL_ROW_103_1482 VGND VPWR sky130_fd_sc_hd__tapvpwrvgnd_1
X_6413_ _6604_/A VGND VGND VPWR VPWR _6413_/Y sky130_fd_sc_hd__inv_2
X_4674_ _6989_/Q _4677_/B VGND VGND VPWR VPWR _4674_/X sky130_fd_sc_hd__or2_2
X_7393_ _7398_/CLK _7393_/D _6673_/Y VGND VGND VPWR VPWR _7393_/Q sky130_fd_sc_hd__dfrtp_2
X_3625_ _3618_/X _3619_/Y _3620_/X _3624_/X VGND VGND VPWR VPWR _3625_/X sky130_fd_sc_hd__a31o_2
X_6344_ _6347_/A VGND VGND VPWR VPWR _6344_/Y sky130_fd_sc_hd__inv_2
X_3556_ _3556_/A _3556_/B _3556_/C VGND VGND VPWR VPWR _3556_/X sky130_fd_sc_hd__or3_2
XFILLER_103_604 VGND VGND VPWR VPWR sky130_fd_sc_hd__decap_3
XFILLER_103_626 VGND VGND VPWR VPWR sky130_fd_sc_hd__decap_3
XFILLER_88_304 VGND VGND VPWR VPWR sky130_fd_sc_hd__decap_3
X_6275_ _6275_/A VGND VGND VPWR VPWR _6275_/Y sky130_fd_sc_hd__inv_2
XPHY_EDGE_ROW_47_Left_164 VGND VGND VPWR VPWR sky130_fd_sc_hd__decap_3
XFILLER_103_659 VGND VGND VPWR VPWR sky130_fd_sc_hd__decap_3
XFILLER_88_326 VGND VGND VPWR VPWR sky130_fd_sc_hd__decap_3
X_3487_ wire568/X _3469_/B _3449_/A _7247_/Q _3365_/A VGND VGND VPWR VPWR _3487_/X
+ sky130_fd_sc_hd__o2111a_2
XFILLER_56_201 VGND VGND VPWR VPWR sky130_fd_sc_hd__decap_3
X_5157_ _7248_/Q _5156_/X _5157_/S VGND VGND VPWR VPWR _7248_/D sky130_fd_sc_hd__mux2_2
XFILLER_110_180 VGND VGND VPWR VPWR sky130_fd_sc_hd__decap_3
XFILLER_56_245 VGND VGND VPWR VPWR sky130_fd_sc_hd__decap_3
XFILLER_56_256 VGND VGND VPWR VPWR sky130_fd_sc_hd__decap_3
X_5088_ _5086_/A _4365_/X _5086_/X _5087_/Y _5020_/A VGND VGND VPWR VPWR _5088_/X
+ sky130_fd_sc_hd__a2111o_2
X_4108_ _4394_/A _4394_/B _4107_/X VGND VGND VPWR VPWR _4142_/C sky130_fd_sc_hd__or3b_2
XFILLER_112_23 VGND VGND VPWR VPWR sky130_fd_sc_hd__decap_3
X_4039_ _4039_/A _4458_/A VGND VGND VPWR VPWR _4040_/B sky130_fd_sc_hd__and2_2
XTAP_TAPCELL_ROW_55_914 VGND VPWR sky130_fd_sc_hd__tapvpwrvgnd_1
XFILLER_112_56 VGND VGND VPWR VPWR sky130_fd_sc_hd__decap_3
XFILLER_72_49 VGND VGND VPWR VPWR sky130_fd_sc_hd__decap_3
XPHY_EDGE_ROW_56_Left_173 VGND VGND VPWR VPWR sky130_fd_sc_hd__decap_3
XFILLER_12_304 VGND VGND VPWR VPWR sky130_fd_sc_hd__decap_3
XFILLER_12_315 VGND VGND VPWR VPWR sky130_fd_sc_hd__decap_3
XTAP_TAPCELL_ROW_35_671 VGND VPWR sky130_fd_sc_hd__tapvpwrvgnd_1
XFILLER_12_337 VGND VGND VPWR VPWR sky130_fd_sc_hd__decap_3
XFILLER_24_197 VGND VGND VPWR VPWR sky130_fd_sc_hd__decap_3
XFILLER_40_679 VGND VGND VPWR VPWR sky130_fd_sc_hd__decap_3
XFILLER_106_442 VGND VGND VPWR VPWR sky130_fd_sc_hd__decap_3
XFILLER_4_536 VGND VGND VPWR VPWR sky130_fd_sc_hd__decap_3
XFILLER_4_558 VGND VGND VPWR VPWR sky130_fd_sc_hd__decap_3
XPHY_EDGE_ROW_65_Left_182 VGND VGND VPWR VPWR sky130_fd_sc_hd__decap_3
XFILLER_106_475 VGND VGND VPWR VPWR sky130_fd_sc_hd__fill_1
XFILLER_79_315 VGND VGND VPWR VPWR sky130_fd_sc_hd__decap_3
XFILLER_97_24 VGND VGND VPWR VPWR sky130_fd_sc_hd__decap_3
XFILLER_79_337 VGND VGND VPWR VPWR sky130_fd_sc_hd__decap_3
XFILLER_97_57 VGND VGND VPWR VPWR sky130_fd_sc_hd__fill_1
XTAP_TAPCELL_ROW_7_341 VGND VPWR sky130_fd_sc_hd__tapvpwrvgnd_1
XTAP_TAPCELL_ROW_7_330 VGND VPWR sky130_fd_sc_hd__tapvpwrvgnd_1
XFILLER_102_681 VGND VGND VPWR VPWR sky130_fd_sc_hd__decap_3
XFILLER_75_532 VGND VGND VPWR VPWR sky130_fd_sc_hd__fill_1
XFILLER_75_587 VGND VGND VPWR VPWR sky130_fd_sc_hd__decap_3
XPHY_EDGE_ROW_74_Left_191 VGND VGND VPWR VPWR sky130_fd_sc_hd__decap_3
XFILLER_16_610 VGND VGND VPWR VPWR sky130_fd_sc_hd__decap_3
XFILLER_16_654 VGND VGND VPWR VPWR sky130_fd_sc_hd__decap_3
XFILLER_62_259 VGND VGND VPWR VPWR sky130_fd_sc_hd__decap_3
XFILLER_15_164 VGND VGND VPWR VPWR sky130_fd_sc_hd__decap_3
XFILLER_43_484 VGND VGND VPWR VPWR sky130_fd_sc_hd__decap_3
XFILLER_62_71 VGND VGND VPWR VPWR sky130_fd_sc_hd__fill_1
XFILLER_11_381 VGND VGND VPWR VPWR sky130_fd_sc_hd__decap_3
XFILLER_30_189 VGND VGND VPWR VPWR sky130_fd_sc_hd__decap_3
XFILLER_7_33 VGND VGND VPWR VPWR sky130_fd_sc_hd__decap_3
XTAP_TAPCELL_ROW_96_1404 VGND VPWR sky130_fd_sc_hd__tapvpwrvgnd_1
XFILLER_116_206 VGND VGND VPWR VPWR sky130_fd_sc_hd__decap_3
XFILLER_116_228 VGND VGND VPWR VPWR sky130_fd_sc_hd__decap_3
XFILLER_7_66 VGND VGND VPWR VPWR sky130_fd_sc_hd__decap_3
XFILLER_7_396 VGND VGND VPWR VPWR sky130_fd_sc_hd__decap_3
XFILLER_7_99 VGND VGND VPWR VPWR sky130_fd_sc_hd__decap_3
X_4390_ _7241_/Q _4433_/B _3958_/S _7209_/Q VGND VGND VPWR VPWR _4390_/X sky130_fd_sc_hd__a22o_2
X_3410_ _7219_/Q _4331_/A2 _4522_/S _7032_/Q VGND VGND VPWR VPWR _3410_/X sky130_fd_sc_hd__a22o_2
X_3341_ _3341_/A VGND VGND VPWR VPWR _5642_/A sky130_fd_sc_hd__inv_2
XFILLER_98_624 VGND VGND VPWR VPWR sky130_fd_sc_hd__decap_3
XFILLER_97_123 VGND VGND VPWR VPWR sky130_fd_sc_hd__decap_3
XFILLER_98_657 VGND VGND VPWR VPWR sky130_fd_sc_hd__decap_3
XFILLER_97_145 VGND VGND VPWR VPWR sky130_fd_sc_hd__decap_3
XFILLER_100_629 VGND VGND VPWR VPWR sky130_fd_sc_hd__decap_3
XFILLER_112_489 VGND VGND VPWR VPWR sky130_fd_sc_hd__decap_3
Xhold1008 _7193_/Q VGND VGND VPWR VPWR _5274_/A0 sky130_fd_sc_hd__dlygate4sd3_1
Xhold1019 _7184_/Q VGND VGND VPWR VPWR _5290_/A0 sky130_fd_sc_hd__dlygate4sd3_1
X_5011_ _4836_/S _6991_/D _5010_/X VGND VGND VPWR VPWR _5011_/X sky130_fd_sc_hd__o21a_2
XFILLER_78_392 VGND VGND VPWR VPWR sky130_fd_sc_hd__decap_3
XFILLER_38_256 VGND VGND VPWR VPWR sky130_fd_sc_hd__decap_3
XFILLER_38_278 VGND VGND VPWR VPWR sky130_fd_sc_hd__decap_3
XFILLER_66_598 VGND VGND VPWR VPWR sky130_fd_sc_hd__decap_3
XFILLER_93_362 VGND VGND VPWR VPWR sky130_fd_sc_hd__fill_1
XFILLER_19_481 VGND VGND VPWR VPWR sky130_fd_sc_hd__decap_3
XFILLER_53_237 VGND VGND VPWR VPWR sky130_fd_sc_hd__decap_3
XFILLER_81_557 VGND VGND VPWR VPWR sky130_fd_sc_hd__decap_3
XFILLER_93_384 VGND VGND VPWR VPWR sky130_fd_sc_hd__decap_3
X_6962_ _6971_/CLK _6962_/D VGND VGND VPWR VPWR _6962_/Q sky130_fd_sc_hd__dfxtp_2
XTAP_TAPCELL_ROW_105_1511 VGND VPWR sky130_fd_sc_hd__tapvpwrvgnd_1
XFILLER_34_440 VGND VGND VPWR VPWR sky130_fd_sc_hd__fill_1
X_6893_ _7405_/CLK _6893_/D VGND VGND VPWR VPWR _6893_/Q sky130_fd_sc_hd__dfxtp_2
XFILLER_22_613 VGND VGND VPWR VPWR sky130_fd_sc_hd__decap_3
XFILLER_22_624 VGND VGND VPWR VPWR sky130_fd_sc_hd__fill_1
XFILLER_34_462 VGND VGND VPWR VPWR sky130_fd_sc_hd__decap_3
XFILLER_34_473 VGND VGND VPWR VPWR sky130_fd_sc_hd__decap_3
XFILLER_61_281 VGND VGND VPWR VPWR sky130_fd_sc_hd__fill_2
XFILLER_61_292 VGND VGND VPWR VPWR sky130_fd_sc_hd__fill_1
XTAP_TAPCELL_ROW_32_641 VGND VPWR sky130_fd_sc_hd__tapvpwrvgnd_1
XTAP_TAPCELL_ROW_32_630 VGND VPWR sky130_fd_sc_hd__tapvpwrvgnd_1
XTAP_TAPCELL_ROW_60_972 VGND VPWR sky130_fd_sc_hd__tapvpwrvgnd_1
X_4726_ _4799_/A _5655_/A _3670_/X _4467_/B VGND VGND VPWR VPWR _4726_/X sky130_fd_sc_hd__o211a_2
XFILLER_107_228 VGND VGND VPWR VPWR sky130_fd_sc_hd__decap_3
X_4657_ _4720_/A _4655_/X _3548_/X VGND VGND VPWR VPWR _4658_/B sky130_fd_sc_hd__a21oi_2
X_7376_ _7387_/CLK _7376_/D _6656_/Y VGND VGND VPWR VPWR _7376_/Q sky130_fd_sc_hd__dfrtp_2
Xhold820 _6751_/Q VGND VGND VPWR VPWR _6751_/D sky130_fd_sc_hd__dlygate4sd3_1
XTAP_TAPCELL_ROW_116_1651 VGND VPWR sky130_fd_sc_hd__tapvpwrvgnd_1
XTAP_TAPCELL_ROW_116_1640 VGND VPWR sky130_fd_sc_hd__tapvpwrvgnd_1
XFILLER_107_23 VGND VGND VPWR VPWR sky130_fd_sc_hd__decap_3
Xhold831 _6812_/Q VGND VGND VPWR VPWR _6812_/D sky130_fd_sc_hd__dlygate4sd3_1
Xhold842 _6894_/Q VGND VGND VPWR VPWR _6894_/D sky130_fd_sc_hd__dlygate4sd3_1
Xhold853 _7068_/Q VGND VGND VPWR VPWR _7068_/D sky130_fd_sc_hd__dlygate4sd3_1
Xhold864 _7084_/Q VGND VGND VPWR VPWR _7084_/D sky130_fd_sc_hd__dlygate4sd3_1
Xmax_cap572 _6525_/A VGND VGND VPWR VPWR _6617_/A sky130_fd_sc_hd__clkbuf_2
Xmax_cap561 _4620_/C VGND VGND VPWR VPWR _4987_/A sky130_fd_sc_hd__clkbuf_2
X_6327_ _6675_/A VGND VGND VPWR VPWR _6327_/Y sky130_fd_sc_hd__inv_2
XFILLER_115_261 VGND VGND VPWR VPWR sky130_fd_sc_hd__decap_3
XFILLER_1_528 VGND VGND VPWR VPWR sky130_fd_sc_hd__decap_3
XFILLER_88_123 VGND VGND VPWR VPWR sky130_fd_sc_hd__decap_3
XFILLER_89_635 VGND VGND VPWR VPWR sky130_fd_sc_hd__decap_3
Xhold875 _7114_/Q VGND VGND VPWR VPWR _7114_/D sky130_fd_sc_hd__dlygate4sd3_1
Xhold886 _7070_/Q VGND VGND VPWR VPWR _7070_/D sky130_fd_sc_hd__dlygate4sd3_1
Xhold897 _7093_/Q VGND VGND VPWR VPWR _7093_/D sky130_fd_sc_hd__dlygate4sd3_1
X_3539_ _3544_/A _3544_/B VGND VGND VPWR VPWR _3547_/A sky130_fd_sc_hd__nand2_2
XFILLER_103_467 VGND VGND VPWR VPWR sky130_fd_sc_hd__decap_3
XFILLER_107_78 VGND VGND VPWR VPWR sky130_fd_sc_hd__decap_3
XFILLER_67_27 VGND VGND VPWR VPWR sky130_fd_sc_hd__decap_3
XFILLER_89_668 VGND VGND VPWR VPWR sky130_fd_sc_hd__decap_3
XFILLER_89_679 VGND VGND VPWR VPWR sky130_fd_sc_hd__decap_3
XTAP_TAPCELL_ROW_4_300 VGND VPWR sky130_fd_sc_hd__tapvpwrvgnd_1
XFILLER_103_489 VGND VGND VPWR VPWR sky130_fd_sc_hd__decap_3
X_5209_ _5209_/A _5221_/B VGND VGND VPWR VPWR _7224_/D sky130_fd_sc_hd__and2_2
XFILLER_29_245 VGND VGND VPWR VPWR sky130_fd_sc_hd__decap_3
XFILLER_57_532 VGND VGND VPWR VPWR sky130_fd_sc_hd__decap_3
XFILLER_29_267 VGND VGND VPWR VPWR sky130_fd_sc_hd__decap_3
XFILLER_57_576 VGND VGND VPWR VPWR sky130_fd_sc_hd__decap_3
XFILLER_83_15 VGND VGND VPWR VPWR sky130_fd_sc_hd__decap_3
XFILLER_84_362 VGND VGND VPWR VPWR sky130_fd_sc_hd__fill_2
XFILLER_16_53 VGND VGND VPWR VPWR sky130_fd_sc_hd__decap_3
XFILLER_12_101 VGND VGND VPWR VPWR sky130_fd_sc_hd__decap_3
XFILLER_13_613 VGND VGND VPWR VPWR sky130_fd_sc_hd__decap_3
XFILLER_25_484 VGND VGND VPWR VPWR sky130_fd_sc_hd__decap_3
XFILLER_40_410 VGND VGND VPWR VPWR sky130_fd_sc_hd__decap_3
XTAP_TAPCELL_ROW_80_1216 VGND VPWR sky130_fd_sc_hd__tapvpwrvgnd_1
XFILLER_40_421 VGND VGND VPWR VPWR sky130_fd_sc_hd__decap_3
XFILLER_13_679 VGND VGND VPWR VPWR sky130_fd_sc_hd__decap_3
XFILLER_40_487 VGND VGND VPWR VPWR sky130_fd_sc_hd__decap_3
XFILLER_8_127 VGND VGND VPWR VPWR sky130_fd_sc_hd__decap_3
XFILLER_12_189 VGND VGND VPWR VPWR sky130_fd_sc_hd__decap_3
XFILLER_21_690 VGND VGND VPWR VPWR sky130_fd_sc_hd__fill_2
XFILLER_32_52 VGND VGND VPWR VPWR sky130_fd_sc_hd__fill_1
XFILLER_32_85 VGND VGND VPWR VPWR sky130_fd_sc_hd__fill_2
XTAP_TAPCELL_ROW_10_368 VGND VPWR sky130_fd_sc_hd__tapvpwrvgnd_1
XFILLER_4_322 VGND VGND VPWR VPWR sky130_fd_sc_hd__decap_3
XFILLER_4_355 VGND VGND VPWR VPWR sky130_fd_sc_hd__fill_1
XTAP_TAPCELL_ROW_78_1189 VGND VPWR sky130_fd_sc_hd__tapvpwrvgnd_1
XFILLER_106_283 VGND VGND VPWR VPWR sky130_fd_sc_hd__decap_3
XFILLER_4_388 VGND VGND VPWR VPWR sky130_fd_sc_hd__decap_3
XTAP_TAPCELL_ROW_91_1345 VGND VPWR sky130_fd_sc_hd__tapvpwrvgnd_1
XFILLER_95_605 VGND VGND VPWR VPWR sky130_fd_sc_hd__decap_3
XFILLER_0_561 VGND VGND VPWR VPWR sky130_fd_sc_hd__decap_3
XFILLER_0_583 VGND VGND VPWR VPWR sky130_fd_sc_hd__decap_3
XFILLER_79_178 VGND VGND VPWR VPWR sky130_fd_sc_hd__fill_1
XFILLER_94_126 VGND VGND VPWR VPWR sky130_fd_sc_hd__decap_3
XFILLER_95_638 VGND VGND VPWR VPWR sky130_fd_sc_hd__decap_3
XFILLER_57_60 VGND VGND VPWR VPWR sky130_fd_sc_hd__fill_2
XFILLER_48_565 VGND VGND VPWR VPWR sky130_fd_sc_hd__decap_3
XFILLER_75_340 VGND VGND VPWR VPWR sky130_fd_sc_hd__decap_3
XFILLER_75_373 VGND VGND VPWR VPWR sky130_fd_sc_hd__decap_3
XFILLER_35_237 VGND VGND VPWR VPWR sky130_fd_sc_hd__decap_3
XFILLER_48_598 VGND VGND VPWR VPWR sky130_fd_sc_hd__decap_3
XFILLER_63_524 VGND VGND VPWR VPWR sky130_fd_sc_hd__decap_3
XFILLER_90_365 VGND VGND VPWR VPWR sky130_fd_sc_hd__decap_3
XTAP_TAPCELL_ROW_18_468 VGND VPWR sky130_fd_sc_hd__tapvpwrvgnd_1
XFILLER_16_473 VGND VGND VPWR VPWR sky130_fd_sc_hd__decap_3
XFILLER_73_81 VGND VGND VPWR VPWR sky130_fd_sc_hd__decap_3
XTAP_TAPCELL_ROW_46_799 VGND VPWR sky130_fd_sc_hd__tapvpwrvgnd_1
XFILLER_31_432 VGND VGND VPWR VPWR sky130_fd_sc_hd__decap_3
XFILLER_43_281 VGND VGND VPWR VPWR sky130_fd_sc_hd__decap_3
X_3890_ _6963_/Q _3892_/A2 _3893_/B1 _6945_/Q VGND VGND VPWR VPWR _3890_/X sky130_fd_sc_hd__a22o_2
XTAP_TAPCELL_ROW_100_1452 VGND VPWR sky130_fd_sc_hd__tapvpwrvgnd_1
XFILLER_31_498 VGND VGND VPWR VPWR sky130_fd_sc_hd__decap_3
XFILLER_78_3 VGND VGND VPWR VPWR sky130_fd_sc_hd__decap_3
XFILLER_8_683 VGND VGND VPWR VPWR sky130_fd_sc_hd__fill_1
X_7230_ _7390_/CLK _7230_/D _6510_/Y VGND VGND VPWR VPWR _7230_/Q sky130_fd_sc_hd__dfrtp_2
X_4442_ _4813_/A _4827_/A VGND VGND VPWR VPWR _4779_/A sky130_fd_sc_hd__or2_2
X_7161_ clkload8/A _7161_/D _6441_/Y VGND VGND VPWR VPWR _7161_/Q sky130_fd_sc_hd__dfrtp_2
X_4373_ _5018_/A _5018_/B VGND VGND VPWR VPWR _4373_/Y sky130_fd_sc_hd__nand2_2
XFILLER_98_421 VGND VGND VPWR VPWR sky130_fd_sc_hd__fill_2
XFILLER_112_242 VGND VGND VPWR VPWR sky130_fd_sc_hd__decap_3
X_7092_ clkload4/A _7092_/D _6372_/Y VGND VGND VPWR VPWR _7092_/Q sky130_fd_sc_hd__dfrtp_2
X_3324_ _3327_/A _4467_/A _4696_/B VGND VGND VPWR VPWR _3324_/X sky130_fd_sc_hd__or3_2
XFILLER_100_404 VGND VGND VPWR VPWR sky130_fd_sc_hd__decap_3
XFILLER_112_264 VGND VGND VPWR VPWR sky130_fd_sc_hd__decap_3
XFILLER_58_318 VGND VGND VPWR VPWR sky130_fd_sc_hd__decap_3
XFILLER_86_627 VGND VGND VPWR VPWR sky130_fd_sc_hd__decap_3
XTAP_TAPCELL_ROW_111_1581 VGND VPWR sky130_fd_sc_hd__tapvpwrvgnd_1
XFILLER_98_498 VGND VGND VPWR VPWR sky130_fd_sc_hd__decap_3
XFILLER_85_137 VGND VGND VPWR VPWR sky130_fd_sc_hd__decap_3
XFILLER_85_148 VGND VGND VPWR VPWR sky130_fd_sc_hd__decap_3
XFILLER_94_660 VGND VGND VPWR VPWR sky130_fd_sc_hd__decap_3
XTAP_TAPCELL_ROW_37_700 VGND VPWR sky130_fd_sc_hd__tapvpwrvgnd_1
XFILLER_26_215 VGND VGND VPWR VPWR sky130_fd_sc_hd__decap_3
XFILLER_81_332 VGND VGND VPWR VPWR sky130_fd_sc_hd__decap_3
XFILLER_53_18 VGND VGND VPWR VPWR sky130_fd_sc_hd__decap_3
X_6945_ _6970_/CLK _6945_/D VGND VGND VPWR VPWR _6945_/Q sky130_fd_sc_hd__dfxtp_2
X_6876_ _7386_/CLK _6876_/D VGND VGND VPWR VPWR _6876_/Q sky130_fd_sc_hd__dfxtp_2
XFILLER_6_609 VGND VGND VPWR VPWR sky130_fd_sc_hd__fill_2
XFILLER_5_108 VGND VGND VPWR VPWR sky130_fd_sc_hd__decap_3
XFILLER_5_119 VGND VGND VPWR VPWR sky130_fd_sc_hd__decap_3
X_4709_ _7002_/Q _7003_/Q _4826_/A VGND VGND VPWR VPWR _4801_/A sky130_fd_sc_hd__and3_2
XFILLER_116_592 VGND VGND VPWR VPWR sky130_fd_sc_hd__decap_3
XFILLER_78_48 VGND VGND VPWR VPWR sky130_fd_sc_hd__decap_3
X_7359_ _7364_/CLK _7359_/D _6639_/Y VGND VGND VPWR VPWR _7359_/Q sky130_fd_sc_hd__dfrtp_2
Xhold650 _6905_/Q VGND VGND VPWR VPWR _6905_/D sky130_fd_sc_hd__dlygate4sd3_1
Xhold661 _6887_/Q VGND VGND VPWR VPWR _6887_/D sky130_fd_sc_hd__dlygate4sd3_1
Xhold672 _6865_/Q VGND VGND VPWR VPWR _6865_/D sky130_fd_sc_hd__dlygate4sd3_1
XFILLER_103_220 VGND VGND VPWR VPWR sky130_fd_sc_hd__decap_3
XFILLER_1_358 VGND VGND VPWR VPWR sky130_fd_sc_hd__decap_3
Xhold683 _6940_/Q VGND VGND VPWR VPWR _6940_/D sky130_fd_sc_hd__dlygate4sd3_1
Xhold694 _6907_/Q VGND VGND VPWR VPWR _6907_/D sky130_fd_sc_hd__dlygate4sd3_1
XFILLER_103_253 VGND VGND VPWR VPWR sky130_fd_sc_hd__fill_2
XFILLER_103_275 VGND VGND VPWR VPWR sky130_fd_sc_hd__decap_3
XFILLER_49_307 VGND VGND VPWR VPWR sky130_fd_sc_hd__decap_3
XFILLER_77_627 VGND VGND VPWR VPWR sky130_fd_sc_hd__decap_3
XFILLER_57_340 VGND VGND VPWR VPWR sky130_fd_sc_hd__decap_3
XFILLER_76_159 VGND VGND VPWR VPWR sky130_fd_sc_hd__decap_3
XFILLER_85_671 VGND VGND VPWR VPWR sky130_fd_sc_hd__fill_1
XFILLER_17_237 VGND VGND VPWR VPWR sky130_fd_sc_hd__decap_3
XFILLER_27_30 VGND VGND VPWR VPWR sky130_fd_sc_hd__decap_3
XFILLER_27_63 VGND VGND VPWR VPWR sky130_fd_sc_hd__decap_3
XFILLER_57_373 VGND VGND VPWR VPWR sky130_fd_sc_hd__decap_3
XFILLER_72_321 VGND VGND VPWR VPWR sky130_fd_sc_hd__decap_3
XFILLER_85_682 VGND VGND VPWR VPWR sky130_fd_sc_hd__decap_3
XFILLER_27_96 VGND VGND VPWR VPWR sky130_fd_sc_hd__decap_3
XFILLER_72_354 VGND VGND VPWR VPWR sky130_fd_sc_hd__decap_3
XFILLER_72_365 VGND VGND VPWR VPWR sky130_fd_sc_hd__fill_2
XFILLER_72_376 VGND VGND VPWR VPWR sky130_fd_sc_hd__decap_3
XFILLER_25_281 VGND VGND VPWR VPWR sky130_fd_sc_hd__fill_2
XFILLER_25_292 VGND VGND VPWR VPWR sky130_fd_sc_hd__decap_3
XTAP_TAPCELL_ROW_43_769 VGND VPWR sky130_fd_sc_hd__tapvpwrvgnd_1
XTAP_TAPCELL_ROW_15_427 VGND VPWR sky130_fd_sc_hd__tapvpwrvgnd_1
XFILLER_5_620 VGND VGND VPWR VPWR sky130_fd_sc_hd__decap_3
XFILLER_64_9 VGND VGND VPWR VPWR sky130_fd_sc_hd__decap_3
XFILLER_4_130 VGND VGND VPWR VPWR sky130_fd_sc_hd__decap_3
XFILLER_4_141 VGND VGND VPWR VPWR sky130_fd_sc_hd__decap_3
XFILLER_99_218 VGND VGND VPWR VPWR sky130_fd_sc_hd__decap_3
XFILLER_4_12 VGND VGND VPWR VPWR sky130_fd_sc_hd__decap_3
XFILLER_4_56 VGND VGND VPWR VPWR sky130_fd_sc_hd__decap_3
XFILLER_68_638 VGND VGND VPWR VPWR sky130_fd_sc_hd__decap_3
XFILLER_95_402 VGND VGND VPWR VPWR sky130_fd_sc_hd__decap_3
XFILLER_0_391 VGND VGND VPWR VPWR sky130_fd_sc_hd__fill_1
XFILLER_67_137 VGND VGND VPWR VPWR sky130_fd_sc_hd__decap_3
XFILLER_95_446 VGND VGND VPWR VPWR sky130_fd_sc_hd__fill_2
XFILLER_48_351 VGND VGND VPWR VPWR sky130_fd_sc_hd__decap_3
XFILLER_67_159 VGND VGND VPWR VPWR sky130_fd_sc_hd__decap_3
XFILLER_76_660 VGND VGND VPWR VPWR sky130_fd_sc_hd__decap_3
XFILLER_48_395 VGND VGND VPWR VPWR sky130_fd_sc_hd__decap_3
XFILLER_63_321 VGND VGND VPWR VPWR sky130_fd_sc_hd__decap_3
XFILLER_75_181 VGND VGND VPWR VPWR sky130_fd_sc_hd__decap_3
XFILLER_91_641 VGND VGND VPWR VPWR sky130_fd_sc_hd__decap_3
Xplace321 _4341_/A2 VGND VGND VPWR VPWR _4356_/A2 sky130_fd_sc_hd__buf_2
Xplace310 _4571_/B VGND VGND VPWR VPWR _4563_/B sky130_fd_sc_hd__buf_2
XFILLER_51_516 VGND VGND VPWR VPWR sky130_fd_sc_hd__decap_3
XFILLER_63_376 VGND VGND VPWR VPWR sky130_fd_sc_hd__fill_2
XFILLER_90_162 VGND VGND VPWR VPWR sky130_fd_sc_hd__decap_3
XFILLER_91_685 VGND VGND VPWR VPWR sky130_fd_sc_hd__decap_3
Xplace354 _4901_/S VGND VGND VPWR VPWR _4837_/S sky130_fd_sc_hd__buf_2
Xplace343 _5072_/A VGND VGND VPWR VPWR _5114_/A sky130_fd_sc_hd__buf_2
Xplace332 _4351_/B1 VGND VGND VPWR VPWR _4195_/A2 sky130_fd_sc_hd__buf_2
X_6730_ _6972_/CLK _6730_/D VGND VGND VPWR VPWR _6730_/Q sky130_fd_sc_hd__dfxtp_2
X_4991_ _5004_/A _5004_/B _4988_/A VGND VGND VPWR VPWR _4991_/Y sky130_fd_sc_hd__a21oi_2
XFILLER_90_195 VGND VGND VPWR VPWR sky130_fd_sc_hd__fill_1
Xplace387 _5622_/B VGND VGND VPWR VPWR _5633_/B sky130_fd_sc_hd__buf_2
Xplace398 _4510_/S VGND VGND VPWR VPWR _4517_/S sky130_fd_sc_hd__buf_2
Xplace376 _3442_/A VGND VGND VPWR VPWR _4791_/A1 sky130_fd_sc_hd__buf_2
Xplace365 _4305_/B VGND VGND VPWR VPWR _3577_/B sky130_fd_sc_hd__buf_2
XFILLER_31_240 VGND VGND VPWR VPWR sky130_fd_sc_hd__decap_3
X_6661_ _6686_/A VGND VGND VPWR VPWR _6661_/Y sky130_fd_sc_hd__inv_2
X_3873_ _3733_/X _3870_/X _3872_/X _5660_/A VGND VGND VPWR VPWR _3874_/B sky130_fd_sc_hd__a22o_2
X_6592_ _6634_/A VGND VGND VPWR VPWR _6592_/Y sky130_fd_sc_hd__inv_2
XFILLER_8_480 VGND VGND VPWR VPWR sky130_fd_sc_hd__decap_3
X_7213_ _7374_/CLK _7213_/D _6493_/Y VGND VGND VPWR VPWR _7213_/Q sky130_fd_sc_hd__dfrtp_2
X_4425_ _4425_/A _4649_/B _4425_/C VGND VGND VPWR VPWR _4426_/B sky130_fd_sc_hd__and3_2
XTAP_TAPCELL_ROW_113_1610 VGND VPWR sky130_fd_sc_hd__tapvpwrvgnd_1
XFILLER_59_605 VGND VGND VPWR VPWR sky130_fd_sc_hd__decap_3
X_7144_ _7368_/CLK _7144_/D _6424_/Y VGND VGND VPWR VPWR _7144_/Q sky130_fd_sc_hd__dfrtp_2
X_4356_ _7012_/Q _4356_/A2 _4272_/B _7353_/Q _4355_/X VGND VGND VPWR VPWR _4356_/X
+ sky130_fd_sc_hd__a221o_2
XFILLER_98_240 VGND VGND VPWR VPWR sky130_fd_sc_hd__decap_3
XFILLER_113_573 VGND VGND VPWR VPWR sky130_fd_sc_hd__decap_3
XFILLER_48_18 VGND VGND VPWR VPWR sky130_fd_sc_hd__decap_3
XFILLER_59_638 VGND VGND VPWR VPWR sky130_fd_sc_hd__decap_3
X_7075_ _7234_/CLK _7075_/D _6355_/Y VGND VGND VPWR VPWR _7075_/Q sky130_fd_sc_hd__dfrtp_2
X_4287_ _7286_/Q _5159_/S _4334_/B1 _7158_/Q VGND VGND VPWR VPWR _4288_/D sky130_fd_sc_hd__a22o_2
XFILLER_98_284 VGND VGND VPWR VPWR sky130_fd_sc_hd__decap_3
XFILLER_100_256 VGND VGND VPWR VPWR sky130_fd_sc_hd__decap_3
XFILLER_104_24 VGND VGND VPWR VPWR sky130_fd_sc_hd__decap_3
XFILLER_104_35 VGND VGND VPWR VPWR sky130_fd_sc_hd__fill_1
XFILLER_27_502 VGND VGND VPWR VPWR sky130_fd_sc_hd__fill_2
XFILLER_58_159 VGND VGND VPWR VPWR sky130_fd_sc_hd__decap_3
XFILLER_67_671 VGND VGND VPWR VPWR sky130_fd_sc_hd__fill_1
XFILLER_39_373 VGND VGND VPWR VPWR sky130_fd_sc_hd__decap_3
XFILLER_67_682 VGND VGND VPWR VPWR sky130_fd_sc_hd__decap_3
XFILLER_66_192 VGND VGND VPWR VPWR sky130_fd_sc_hd__decap_3
XFILLER_81_140 VGND VGND VPWR VPWR sky130_fd_sc_hd__decap_3
XFILLER_82_663 VGND VGND VPWR VPWR sky130_fd_sc_hd__decap_3
XFILLER_14_218 VGND VGND VPWR VPWR sky130_fd_sc_hd__decap_3
XFILLER_42_516 VGND VGND VPWR VPWR sky130_fd_sc_hd__fill_1
XFILLER_54_365 VGND VGND VPWR VPWR sky130_fd_sc_hd__decap_3
XTAP_TAPCELL_ROW_64_1019 VGND VPWR sky130_fd_sc_hd__tapvpwrvgnd_1
XFILLER_54_398 VGND VGND VPWR VPWR sky130_fd_sc_hd__decap_3
XFILLER_81_195 VGND VGND VPWR VPWR sky130_fd_sc_hd__decap_3
Xfanout22 _6600_/A VGND VGND VPWR VPWR _6632_/A sky130_fd_sc_hd__clkdlybuf4s25_1
X_6928_ _7392_/CLK _6928_/D VGND VGND VPWR VPWR _6928_/Q sky130_fd_sc_hd__dfxtp_2
XFILLER_22_240 VGND VGND VPWR VPWR sky130_fd_sc_hd__decap_3
XFILLER_80_27 VGND VGND VPWR VPWR sky130_fd_sc_hd__fill_1
Xfanout33 fanout38/X VGND VGND VPWR VPWR _6606_/A sky130_fd_sc_hd__buf_1
Xfanout44 _6643_/A VGND VGND VPWR VPWR _6642_/A sky130_fd_sc_hd__buf_2
Xfanout55 _6684_/A VGND VGND VPWR VPWR _6674_/A sky130_fd_sc_hd__buf_2
X_6859_ _6946_/CLK _6859_/D VGND VGND VPWR VPWR _6859_/Q sky130_fd_sc_hd__dfxtp_2
XFILLER_13_32 VGND VGND VPWR VPWR sky130_fd_sc_hd__decap_3
XFILLER_22_273 VGND VGND VPWR VPWR sky130_fd_sc_hd__decap_3
Xfanout66 _6619_/A VGND VGND VPWR VPWR _6651_/A sky130_fd_sc_hd__buf_2
XTAP_TAPCELL_ROW_40_728 VGND VPWR sky130_fd_sc_hd__tapvpwrvgnd_1
XFILLER_108_301 VGND VGND VPWR VPWR sky130_fd_sc_hd__decap_3
XFILLER_10_457 VGND VGND VPWR VPWR sky130_fd_sc_hd__fill_2
XFILLER_6_417 VGND VGND VPWR VPWR sky130_fd_sc_hd__decap_3
XFILLER_6_439 VGND VGND VPWR VPWR sky130_fd_sc_hd__decap_3
XFILLER_89_47 VGND VGND VPWR VPWR sky130_fd_sc_hd__decap_3
XTAP_TAPCELL_ROW_20_496 VGND VPWR sky130_fd_sc_hd__tapvpwrvgnd_1
XFILLER_2_601 VGND VGND VPWR VPWR sky130_fd_sc_hd__decap_3
XTAP_TAPCELL_ROW_75_1148 VGND VPWR sky130_fd_sc_hd__tapvpwrvgnd_1
XFILLER_1_111 VGND VGND VPWR VPWR sky130_fd_sc_hd__fill_1
XFILLER_1_122 VGND VGND VPWR VPWR sky130_fd_sc_hd__decap_3
XFILLER_2_645 VGND VGND VPWR VPWR sky130_fd_sc_hd__decap_3
XFILLER_1_155 VGND VGND VPWR VPWR sky130_fd_sc_hd__decap_3
XFILLER_2_678 VGND VGND VPWR VPWR sky130_fd_sc_hd__decap_3
XFILLER_77_435 VGND VGND VPWR VPWR sky130_fd_sc_hd__decap_3
XFILLER_89_284 VGND VGND VPWR VPWR sky130_fd_sc_hd__fill_1
XFILLER_49_159 VGND VGND VPWR VPWR sky130_fd_sc_hd__decap_3
XFILLER_58_660 VGND VGND VPWR VPWR sky130_fd_sc_hd__decap_3
XTAP_TAPCELL_ROW_48_828 VGND VPWR sky130_fd_sc_hd__tapvpwrvgnd_1
XFILLER_73_641 VGND VGND VPWR VPWR sky130_fd_sc_hd__decap_3
Xhold1180 _7176_/Q VGND VGND VPWR VPWR _5308_/A0 sky130_fd_sc_hd__dlygate4sd3_1
Xhold1191 _7223_/Q VGND VGND VPWR VPWR _5211_/A sky130_fd_sc_hd__dlygate4sd3_1
XFILLER_72_162 VGND VGND VPWR VPWR sky130_fd_sc_hd__decap_3
XTAP_TAPCELL_ROW_86_1288 VGND VPWR sky130_fd_sc_hd__tapvpwrvgnd_1
XFILLER_54_83 VGND VGND VPWR VPWR sky130_fd_sc_hd__fill_1
XTAP_TAPCELL_ROW_28_585 VGND VPWR sky130_fd_sc_hd__tapvpwrvgnd_1
XFILLER_13_240 VGND VGND VPWR VPWR sky130_fd_sc_hd__decap_3
XFILLER_54_94 VGND VGND VPWR VPWR sky130_fd_sc_hd__decap_3
XFILLER_60_379 VGND VGND VPWR VPWR sky130_fd_sc_hd__decap_3
XFILLER_13_262 VGND VGND VPWR VPWR sky130_fd_sc_hd__decap_3
XFILLER_13_284 VGND VGND VPWR VPWR sky130_fd_sc_hd__decap_3
XFILLER_9_222 VGND VGND VPWR VPWR sky130_fd_sc_hd__fill_2
XFILLER_62_6 VGND VGND VPWR VPWR sky130_fd_sc_hd__decap_3
Xclkload14 _6970_/CLK VGND VGND VPWR VPWR clkload14/X sky130_fd_sc_hd__clkbuf_8
Xclkload25 _7334_/CLK VGND VGND VPWR VPWR clkload25/X sky130_fd_sc_hd__clkbuf_8
Xclkload36 _7374_/CLK VGND VGND VPWR VPWR clkload36/Y sky130_fd_sc_hd__clkinv_2
XFILLER_114_304 VGND VGND VPWR VPWR sky130_fd_sc_hd__decap_3
XFILLER_5_461 VGND VGND VPWR VPWR sky130_fd_sc_hd__fill_1
XFILLER_114_348 VGND VGND VPWR VPWR sky130_fd_sc_hd__decap_3
X_4210_ _4095_/A _4210_/B VGND VGND VPWR VPWR _4210_/X sky130_fd_sc_hd__and2b_2
XPHY_EDGE_ROW_10_Left_127 VGND VGND VPWR VPWR sky130_fd_sc_hd__decap_3
XFILLER_68_402 VGND VGND VPWR VPWR sky130_fd_sc_hd__decap_3
X_5190_ _5190_/A _5205_/B VGND VGND VPWR VPWR _7233_/D sky130_fd_sc_hd__and2_2
XFILLER_68_424 VGND VGND VPWR VPWR sky130_fd_sc_hd__decap_3
X_4141_ _4141_/A _4141_/B VGND VGND VPWR VPWR _4142_/B sky130_fd_sc_hd__nor2_2
XFILLER_110_554 VGND VGND VPWR VPWR sky130_fd_sc_hd__decap_3
XFILLER_56_619 VGND VGND VPWR VPWR sky130_fd_sc_hd__decap_3
XFILLER_83_405 VGND VGND VPWR VPWR sky130_fd_sc_hd__decap_3
XFILLER_95_243 VGND VGND VPWR VPWR sky130_fd_sc_hd__decap_3
X_4072_ _7243_/Q _4430_/A2 _4430_/B1 _7179_/Q _4071_/X VGND VGND VPWR VPWR _4072_/X
+ sky130_fd_sc_hd__a221o_2
XFILLER_110_587 VGND VGND VPWR VPWR sky130_fd_sc_hd__fill_1
XFILLER_110_598 VGND VGND VPWR VPWR sky130_fd_sc_hd__decap_3
XFILLER_49_671 VGND VGND VPWR VPWR sky130_fd_sc_hd__fill_1
XFILLER_49_682 VGND VGND VPWR VPWR sky130_fd_sc_hd__decap_3
XFILLER_55_118 VGND VGND VPWR VPWR sky130_fd_sc_hd__decap_3
XFILLER_83_427 VGND VGND VPWR VPWR sky130_fd_sc_hd__decap_3
XFILLER_83_449 VGND VGND VPWR VPWR sky130_fd_sc_hd__decap_3
XFILLER_95_276 VGND VGND VPWR VPWR sky130_fd_sc_hd__decap_3
XFILLER_36_332 VGND VGND VPWR VPWR sky130_fd_sc_hd__decap_3
XFILLER_36_354 VGND VGND VPWR VPWR sky130_fd_sc_hd__fill_1
XFILLER_48_192 VGND VGND VPWR VPWR sky130_fd_sc_hd__decap_3
XFILLER_64_663 VGND VGND VPWR VPWR sky130_fd_sc_hd__decap_3
XFILLER_36_365 VGND VGND VPWR VPWR sky130_fd_sc_hd__decap_3
XFILLER_91_482 VGND VGND VPWR VPWR sky130_fd_sc_hd__decap_3
XFILLER_51_346 VGND VGND VPWR VPWR sky130_fd_sc_hd__decap_3
X_4974_ _6993_/Q _4983_/B VGND VGND VPWR VPWR _4975_/B sky130_fd_sc_hd__xor2_2
XFILLER_51_379 VGND VGND VPWR VPWR sky130_fd_sc_hd__decap_3
X_6713_ _7374_/CLK _6713_/D VGND VGND VPWR VPWR _6713_/Q sky130_fd_sc_hd__dfxtp_2
X_3925_ _6687_/Q _3925_/A2 _3925_/B1 _6865_/Q VGND VGND VPWR VPWR _3925_/X sky130_fd_sc_hd__a22o_2
X_6644_ _6644_/A VGND VGND VPWR VPWR _6644_/Y sky130_fd_sc_hd__inv_2
Xclkload8 clkload8/A VGND VGND VPWR VPWR clkload8/Y sky130_fd_sc_hd__clkinv_2
X_3856_ _3845_/X _3855_/X _5151_/A VGND VGND VPWR VPWR _3856_/X sky130_fd_sc_hd__o21a_2
X_6575_ _6608_/A VGND VGND VPWR VPWR _6575_/Y sky130_fd_sc_hd__inv_2
X_3787_ _6739_/Q _3651_/Y _3892_/B1 _6745_/Q _3786_/X VGND VGND VPWR VPWR _3787_/X
+ sky130_fd_sc_hd__a221o_2
XFILLER_105_337 VGND VGND VPWR VPWR sky130_fd_sc_hd__fill_2
XFILLER_105_348 VGND VGND VPWR VPWR sky130_fd_sc_hd__decap_3
XFILLER_59_39 VGND VGND VPWR VPWR sky130_fd_sc_hd__decap_3
Xoutput552 _6985_/Q VGND VGND VPWR VPWR pc_out[8] sky130_fd_sc_hd__clkdlybuf4s25_1
Xoutput541 _7004_/Q VGND VGND VPWR VPWR pc_out[27] sky130_fd_sc_hd__clkdlybuf4s25_1
Xoutput530 _6994_/Q VGND VGND VPWR VPWR pc_out[17] sky130_fd_sc_hd__clkdlybuf4s25_1
X_4408_ _7024_/Q _4422_/A2 _4404_/X _4407_/X VGND VGND VPWR VPWR _4409_/B sky130_fd_sc_hd__a211o_2
X_5388_ _5388_/A0 _4913_/X _5396_/S VGND VGND VPWR VPWR _7139_/D sky130_fd_sc_hd__mux2_2
XFILLER_115_23 VGND VGND VPWR VPWR sky130_fd_sc_hd__decap_3
X_7127_ clkload5/A _7127_/D _6407_/Y VGND VGND VPWR VPWR _7127_/Q sky130_fd_sc_hd__dfrtp_2
X_4339_ _7287_/Q _4522_/S _4339_/B1 _7159_/Q VGND VGND VPWR VPWR _4339_/X sky130_fd_sc_hd__a22o_2
XFILLER_115_78 VGND VGND VPWR VPWR sky130_fd_sc_hd__decap_3
XFILLER_59_479 VGND VGND VPWR VPWR sky130_fd_sc_hd__fill_2
XFILLER_86_265 VGND VGND VPWR VPWR sky130_fd_sc_hd__decap_3
X_7058_ clkload6/A _7058_/D _6338_/Y VGND VGND VPWR VPWR _7058_/Q sky130_fd_sc_hd__dfstp_2
XTAP_TAPCELL_ROW_70_1089 VGND VPWR sky130_fd_sc_hd__tapvpwrvgnd_1
XFILLER_74_427 VGND VGND VPWR VPWR sky130_fd_sc_hd__fill_2
XFILLER_86_298 VGND VGND VPWR VPWR sky130_fd_sc_hd__fill_1
XFILLER_39_181 VGND VGND VPWR VPWR sky130_fd_sc_hd__fill_1
XFILLER_55_641 VGND VGND VPWR VPWR sky130_fd_sc_hd__decap_3
XFILLER_67_490 VGND VGND VPWR VPWR sky130_fd_sc_hd__decap_3
XFILLER_54_162 VGND VGND VPWR VPWR sky130_fd_sc_hd__decap_3
XFILLER_55_685 VGND VGND VPWR VPWR sky130_fd_sc_hd__decap_3
XFILLER_82_460 VGND VGND VPWR VPWR sky130_fd_sc_hd__decap_3
XFILLER_91_15 VGND VGND VPWR VPWR sky130_fd_sc_hd__decap_3
XFILLER_54_195 VGND VGND VPWR VPWR sky130_fd_sc_hd__fill_1
XFILLER_70_622 VGND VGND VPWR VPWR sky130_fd_sc_hd__decap_3
XFILLER_24_20 VGND VGND VPWR VPWR sky130_fd_sc_hd__decap_3
XFILLER_24_42 VGND VGND VPWR VPWR sky130_fd_sc_hd__decap_3
XFILLER_30_519 VGND VGND VPWR VPWR sky130_fd_sc_hd__decap_3
XFILLER_42_368 VGND VGND VPWR VPWR sky130_fd_sc_hd__fill_2
XFILLER_42_379 VGND VGND VPWR VPWR sky130_fd_sc_hd__decap_3
XFILLER_70_666 VGND VGND VPWR VPWR sky130_fd_sc_hd__decap_3
XTAP_TAPCELL_ROW_25_555 VGND VPWR sky130_fd_sc_hd__tapvpwrvgnd_1
XTAP_TAPCELL_ROW_53_886 VGND VPWR sky130_fd_sc_hd__tapvpwrvgnd_1
XFILLER_10_221 VGND VGND VPWR VPWR sky130_fd_sc_hd__decap_3
XFILLER_24_97 VGND VGND VPWR VPWR sky130_fd_sc_hd__decap_3
XFILLER_109_632 VGND VGND VPWR VPWR sky130_fd_sc_hd__decap_3
XFILLER_10_265 VGND VGND VPWR VPWR sky130_fd_sc_hd__decap_3
XFILLER_109_665 VGND VGND VPWR VPWR sky130_fd_sc_hd__decap_3
XFILLER_109_676 VGND VGND VPWR VPWR sky130_fd_sc_hd__decap_3
XFILLER_40_52 VGND VGND VPWR VPWR sky130_fd_sc_hd__fill_1
XFILLER_40_63 VGND VGND VPWR VPWR sky130_fd_sc_hd__decap_3
XFILLER_108_153 VGND VGND VPWR VPWR sky130_fd_sc_hd__decap_3
XFILLER_108_186 VGND VGND VPWR VPWR sky130_fd_sc_hd__decap_3
XFILLER_40_85 VGND VGND VPWR VPWR sky130_fd_sc_hd__decap_3
XFILLER_40_96 VGND VGND VPWR VPWR sky130_fd_sc_hd__decap_3
XFILLER_108_197 VGND VGND VPWR VPWR sky130_fd_sc_hd__decap_3
XFILLER_97_508 VGND VGND VPWR VPWR sky130_fd_sc_hd__decap_3
XFILLER_2_442 VGND VGND VPWR VPWR sky130_fd_sc_hd__decap_3
XFILLER_2_475 VGND VGND VPWR VPWR sky130_fd_sc_hd__fill_1
XFILLER_104_392 VGND VGND VPWR VPWR sky130_fd_sc_hd__decap_3
XFILLER_49_72 VGND VGND VPWR VPWR sky130_fd_sc_hd__decap_3
XFILLER_77_221 VGND VGND VPWR VPWR sky130_fd_sc_hd__decap_3
XFILLER_27_9 VGND VGND VPWR VPWR sky130_fd_sc_hd__decap_3
XFILLER_65_405 VGND VGND VPWR VPWR sky130_fd_sc_hd__decap_3
XFILLER_77_254 VGND VGND VPWR VPWR sky130_fd_sc_hd__decap_3
XTAP_TAPCELL_ROW_88_1306 VGND VPWR sky130_fd_sc_hd__tapvpwrvgnd_1
XFILLER_1_35 VGND VGND VPWR VPWR sky130_fd_sc_hd__decap_3
XFILLER_77_298 VGND VGND VPWR VPWR sky130_fd_sc_hd__decap_3
XFILLER_1_57 VGND VGND VPWR VPWR sky130_fd_sc_hd__decap_3
XFILLER_46_641 VGND VGND VPWR VPWR sky130_fd_sc_hd__decap_3
XFILLER_65_449 VGND VGND VPWR VPWR sky130_fd_sc_hd__decap_3
XFILLER_65_60 VGND VGND VPWR VPWR sky130_fd_sc_hd__decap_3
XFILLER_18_365 VGND VGND VPWR VPWR sky130_fd_sc_hd__decap_3
XFILLER_46_663 VGND VGND VPWR VPWR sky130_fd_sc_hd__decap_3
XFILLER_61_611 VGND VGND VPWR VPWR sky130_fd_sc_hd__decap_3
XFILLER_65_93 VGND VGND VPWR VPWR sky130_fd_sc_hd__decap_3
XFILLER_33_335 VGND VGND VPWR VPWR sky130_fd_sc_hd__fill_1
XFILLER_33_346 VGND VGND VPWR VPWR sky130_fd_sc_hd__decap_3
XFILLER_45_184 VGND VGND VPWR VPWR sky130_fd_sc_hd__decap_3
XFILLER_61_644 VGND VGND VPWR VPWR sky130_fd_sc_hd__decap_3
XFILLER_60_132 VGND VGND VPWR VPWR sky130_fd_sc_hd__decap_3
XFILLER_60_165 VGND VGND VPWR VPWR sky130_fd_sc_hd__decap_3
XFILLER_61_688 VGND VGND VPWR VPWR sky130_fd_sc_hd__decap_3
XFILLER_60_187 VGND VGND VPWR VPWR sky130_fd_sc_hd__decap_3
X_3710_ hold993/X _3757_/S _3709_/X VGND VGND VPWR VPWR _7399_/D sky130_fd_sc_hd__o21a_2
X_4690_ _7005_/Q _5633_/B VGND VGND VPWR VPWR _4757_/A sky130_fd_sc_hd__and2_2
XTAP_TAPCELL_ROW_99_1435 VGND VPWR sky130_fd_sc_hd__tapvpwrvgnd_1
XFILLER_60_3 VGND VGND VPWR VPWR sky130_fd_sc_hd__decap_3
X_6360_ _6388_/A VGND VGND VPWR VPWR _6360_/Y sky130_fd_sc_hd__inv_2
X_3572_ _4295_/B _3607_/B VGND VGND VPWR VPWR _4292_/A sky130_fd_sc_hd__xnor2_2
XFILLER_115_635 VGND VGND VPWR VPWR sky130_fd_sc_hd__decap_3
XFILLER_114_112 VGND VGND VPWR VPWR sky130_fd_sc_hd__decap_3
XFILLER_115_668 VGND VGND VPWR VPWR sky130_fd_sc_hd__decap_3
X_6291_ _6535_/A VGND VGND VPWR VPWR _6291_/Y sky130_fd_sc_hd__inv_2
XFILLER_102_307 VGND VGND VPWR VPWR sky130_fd_sc_hd__fill_1
XFILLER_102_318 VGND VGND VPWR VPWR sky130_fd_sc_hd__decap_3
XFILLER_114_156 VGND VGND VPWR VPWR sky130_fd_sc_hd__decap_3
XFILLER_115_679 VGND VGND VPWR VPWR sky130_fd_sc_hd__decap_3
XFILLER_114_189 VGND VGND VPWR VPWR sky130_fd_sc_hd__decap_3
X_5173_ _5173_/A _5182_/B VGND VGND VPWR VPWR _7241_/D sky130_fd_sc_hd__and2_2
X_4124_ _4117_/Y _4124_/B VGND VGND VPWR VPWR _4126_/A sky130_fd_sc_hd__and2b_2
XFILLER_110_362 VGND VGND VPWR VPWR sky130_fd_sc_hd__fill_2
XFILLER_68_298 VGND VGND VPWR VPWR sky130_fd_sc_hd__decap_3
XFILLER_56_449 VGND VGND VPWR VPWR sky130_fd_sc_hd__decap_3
XFILLER_83_235 VGND VGND VPWR VPWR sky130_fd_sc_hd__decap_3
X_4055_ _4055_/A _4658_/A VGND VGND VPWR VPWR _4720_/A sky130_fd_sc_hd__nor2b_2
XFILLER_37_685 VGND VGND VPWR VPWR sky130_fd_sc_hd__decap_3
XTAP_TAPCELL_ROW_108_1553 VGND VPWR sky130_fd_sc_hd__tapvpwrvgnd_1
XTAP_TAPCELL_ROW_108_1542 VGND VPWR sky130_fd_sc_hd__tapvpwrvgnd_1
XFILLER_101_14 VGND VGND VPWR VPWR sky130_fd_sc_hd__decap_3
XFILLER_36_184 VGND VGND VPWR VPWR sky130_fd_sc_hd__fill_2
XFILLER_52_622 VGND VGND VPWR VPWR sky130_fd_sc_hd__decap_3
XFILLER_101_47 VGND VGND VPWR VPWR sky130_fd_sc_hd__decap_3
XFILLER_24_379 VGND VGND VPWR VPWR sky130_fd_sc_hd__decap_3
XFILLER_52_666 VGND VGND VPWR VPWR sky130_fd_sc_hd__decap_3
XFILLER_61_18 VGND VGND VPWR VPWR sky130_fd_sc_hd__decap_3
X_4957_ _4982_/B _5009_/A _6992_/Q VGND VGND VPWR VPWR _4983_/B sky130_fd_sc_hd__o21ai_2
XTAP_TAPCELL_ROW_22_514 VGND VPWR sky130_fd_sc_hd__tapvpwrvgnd_1
XFILLER_20_541 VGND VGND VPWR VPWR sky130_fd_sc_hd__decap_3
X_4888_ _4888_/A _4888_/B VGND VGND VPWR VPWR _4889_/B sky130_fd_sc_hd__or2_2
X_3908_ _3728_/B _3907_/X _5151_/A VGND VGND VPWR VPWR _3908_/X sky130_fd_sc_hd__o21a_2
XTAP_TAPCELL_ROW_50_856 VGND VPWR sky130_fd_sc_hd__tapvpwrvgnd_1
XFILLER_20_585 VGND VGND VPWR VPWR sky130_fd_sc_hd__decap_3
X_6627_ _6664_/A VGND VGND VPWR VPWR _6627_/Y sky130_fd_sc_hd__inv_2
X_3839_ _3746_/X _3836_/X _3838_/X _3733_/X VGND VGND VPWR VPWR _3845_/A sky130_fd_sc_hd__a22o_2
XFILLER_20_596 VGND VGND VPWR VPWR sky130_fd_sc_hd__decap_3
X_6558_ _6558_/A VGND VGND VPWR VPWR _6558_/Y sky130_fd_sc_hd__inv_2
XFILLER_106_624 VGND VGND VPWR VPWR sky130_fd_sc_hd__decap_3
XFILLER_106_657 VGND VGND VPWR VPWR sky130_fd_sc_hd__decap_3
XFILLER_10_44 VGND VGND VPWR VPWR sky130_fd_sc_hd__decap_3
XFILLER_3_228 VGND VGND VPWR VPWR sky130_fd_sc_hd__decap_3
X_6489_ _6584_/A VGND VGND VPWR VPWR _6489_/Y sky130_fd_sc_hd__inv_2
XFILLER_105_178 VGND VGND VPWR VPWR sky130_fd_sc_hd__decap_3
XFILLER_10_77 VGND VGND VPWR VPWR sky130_fd_sc_hd__decap_3
XFILLER_10_88 VGND VGND VPWR VPWR sky130_fd_sc_hd__decap_3
XTAP_TAPCELL_ROW_72_1118 VGND VPWR sky130_fd_sc_hd__tapvpwrvgnd_1
XFILLER_114_690 VGND VGND VPWR VPWR sky130_fd_sc_hd__fill_2
XFILLER_59_221 VGND VGND VPWR VPWR sky130_fd_sc_hd__decap_3
XFILLER_86_37 VGND VGND VPWR VPWR sky130_fd_sc_hd__decap_3
XFILLER_99_390 VGND VGND VPWR VPWR sky130_fd_sc_hd__fill_2
XFILLER_101_340 VGND VGND VPWR VPWR sky130_fd_sc_hd__decap_3
XFILLER_19_20 VGND VGND VPWR VPWR sky130_fd_sc_hd__decap_3
XFILLER_87_541 VGND VGND VPWR VPWR sky130_fd_sc_hd__decap_3
XFILLER_19_107 VGND VGND VPWR VPWR sky130_fd_sc_hd__decap_3
XFILLER_47_405 VGND VGND VPWR VPWR sky130_fd_sc_hd__decap_3
XFILLER_59_265 VGND VGND VPWR VPWR sky130_fd_sc_hd__decap_3
XFILLER_28_630 VGND VGND VPWR VPWR sky130_fd_sc_hd__fill_2
XFILLER_47_449 VGND VGND VPWR VPWR sky130_fd_sc_hd__decap_3
Xclkbuf_leaf_39_clk clkbuf_leaf_4_clk/A VGND VGND VPWR VPWR _7360_/CLK sky130_fd_sc_hd__clkbuf_16
XTAP_TAPCELL_ROW_58_945 VGND VPWR sky130_fd_sc_hd__tapvpwrvgnd_1
XFILLER_15_302 VGND VGND VPWR VPWR sky130_fd_sc_hd__decap_3
XFILLER_27_140 VGND VGND VPWR VPWR sky130_fd_sc_hd__decap_3
XFILLER_62_408 VGND VGND VPWR VPWR sky130_fd_sc_hd__decap_3
XFILLER_74_268 VGND VGND VPWR VPWR sky130_fd_sc_hd__decap_3
XTAP_TAPCELL_ROW_2_272 VGND VPWR sky130_fd_sc_hd__tapvpwrvgnd_1
XFILLER_15_335 VGND VGND VPWR VPWR sky130_fd_sc_hd__fill_1
XFILLER_70_430 VGND VGND VPWR VPWR sky130_fd_sc_hd__decap_3
XFILLER_35_74 VGND VGND VPWR VPWR sky130_fd_sc_hd__fill_1
XFILLER_43_666 VGND VGND VPWR VPWR sky130_fd_sc_hd__decap_3
XTAP_TAPCELL_ROW_83_1247 VGND VPWR sky130_fd_sc_hd__tapvpwrvgnd_1
XFILLER_30_327 VGND VGND VPWR VPWR sky130_fd_sc_hd__decap_3
XFILLER_43_688 VGND VGND VPWR VPWR sky130_fd_sc_hd__fill_1
XFILLER_70_474 VGND VGND VPWR VPWR sky130_fd_sc_hd__fill_2
XFILLER_109_495 VGND VGND VPWR VPWR sky130_fd_sc_hd__decap_3
XFILLER_112_616 VGND VGND VPWR VPWR sky130_fd_sc_hd__decap_3
XFILLER_97_305 VGND VGND VPWR VPWR sky130_fd_sc_hd__decap_3
XTAP_TAPCELL_ROW_94_1376 VGND VPWR sky130_fd_sc_hd__tapvpwrvgnd_1
XFILLER_2_261 VGND VGND VPWR VPWR sky130_fd_sc_hd__decap_3
XFILLER_111_137 VGND VGND VPWR VPWR sky130_fd_sc_hd__decap_3
XFILLER_25_6 VGND VGND VPWR VPWR sky130_fd_sc_hd__decap_3
XFILLER_93_511 VGND VGND VPWR VPWR sky130_fd_sc_hd__decap_3
XFILLER_53_408 VGND VGND VPWR VPWR sky130_fd_sc_hd__decap_3
XFILLER_65_279 VGND VGND VPWR VPWR sky130_fd_sc_hd__fill_1
XFILLER_93_588 VGND VGND VPWR VPWR sky130_fd_sc_hd__fill_2
XFILLER_18_195 VGND VGND VPWR VPWR sky130_fd_sc_hd__fill_1
XFILLER_34_611 VGND VGND VPWR VPWR sky130_fd_sc_hd__decap_3
XFILLER_46_493 VGND VGND VPWR VPWR sky130_fd_sc_hd__fill_2
XFILLER_80_227 VGND VGND VPWR VPWR sky130_fd_sc_hd__decap_3
XFILLER_33_143 VGND VGND VPWR VPWR sky130_fd_sc_hd__decap_3
XFILLER_34_666 VGND VGND VPWR VPWR sky130_fd_sc_hd__fill_1
X_4811_ _4652_/B _4811_/B _4811_/C VGND VGND VPWR VPWR _4811_/X sky130_fd_sc_hd__and3b_2
XFILLER_21_305 VGND VGND VPWR VPWR sky130_fd_sc_hd__decap_3
XFILLER_21_349 VGND VGND VPWR VPWR sky130_fd_sc_hd__decap_3
X_4742_ _4069_/Y _4081_/X _4454_/X _4969_/B VGND VGND VPWR VPWR _4742_/Y sky130_fd_sc_hd__o211ai_2
XTAP_TAPCELL_ROW_103_1483 VGND VPWR sky130_fd_sc_hd__tapvpwrvgnd_1
X_4673_ _4982_/B _4673_/B VGND VGND VPWR VPWR _4680_/A sky130_fd_sc_hd__or2_2
X_6412_ _6604_/A VGND VGND VPWR VPWR _6412_/Y sky130_fd_sc_hd__inv_2
X_3624_ _5114_/A _3600_/A _4614_/C _3635_/B VGND VGND VPWR VPWR _3624_/X sky130_fd_sc_hd__a22o_2
X_7392_ _7392_/CLK _7392_/D _6672_/Y VGND VGND VPWR VPWR _7392_/Q sky130_fd_sc_hd__dfrtp_2
XFILLER_115_443 VGND VGND VPWR VPWR sky130_fd_sc_hd__fill_2
X_6343_ _6347_/A VGND VGND VPWR VPWR _6343_/Y sky130_fd_sc_hd__inv_2
X_3555_ _7285_/Q _4522_/S _3366_/X _7157_/Q VGND VGND VPWR VPWR _3556_/C sky130_fd_sc_hd__a22o_2
X_6274_ _6275_/A VGND VGND VPWR VPWR _6274_/Y sky130_fd_sc_hd__inv_2
X_3486_ _3502_/A _3502_/B _3485_/C VGND VGND VPWR VPWR _5144_/B sky130_fd_sc_hd__o21ai_2
XFILLER_102_104 VGND VGND VPWR VPWR sky130_fd_sc_hd__decap_3
XFILLER_103_638 VGND VGND VPWR VPWR sky130_fd_sc_hd__decap_3
XFILLER_88_338 VGND VGND VPWR VPWR sky130_fd_sc_hd__decap_3
X_5225_ _5225_/A _5225_/B VGND VGND VPWR VPWR _7216_/D sky130_fd_sc_hd__and2_2
XFILLER_111_671 VGND VGND VPWR VPWR sky130_fd_sc_hd__fill_1
XFILLER_111_682 VGND VGND VPWR VPWR sky130_fd_sc_hd__decap_3
XFILLER_29_405 VGND VGND VPWR VPWR sky130_fd_sc_hd__decap_3
XFILLER_56_18 VGND VGND VPWR VPWR sky130_fd_sc_hd__decap_3
XFILLER_56_29 VGND VGND VPWR VPWR sky130_fd_sc_hd__decap_3
XFILLER_96_382 VGND VGND VPWR VPWR sky130_fd_sc_hd__decap_3
X_5156_ _7010_/D _5155_/X _5156_/S VGND VGND VPWR VPWR _5156_/X sky130_fd_sc_hd__mux2_2
XFILLER_110_192 VGND VGND VPWR VPWR sky130_fd_sc_hd__decap_3
XFILLER_29_449 VGND VGND VPWR VPWR sky130_fd_sc_hd__decap_3
XFILLER_56_224 VGND VGND VPWR VPWR sky130_fd_sc_hd__decap_3
XFILLER_84_533 VGND VGND VPWR VPWR sky130_fd_sc_hd__decap_3
XFILLER_96_393 VGND VGND VPWR VPWR sky130_fd_sc_hd__decap_3
X_5087_ _5101_/B _5100_/B _5086_/A _4365_/X VGND VGND VPWR VPWR _5087_/Y sky130_fd_sc_hd__a211oi_2
X_4107_ _7301_/Q _4417_/A2 _4250_/A2 _7109_/Q _4106_/X VGND VGND VPWR VPWR _4107_/X
+ sky130_fd_sc_hd__a221o_2
XFILLER_44_408 VGND VGND VPWR VPWR sky130_fd_sc_hd__fill_2
XFILLER_56_268 VGND VGND VPWR VPWR sky130_fd_sc_hd__decap_3
XFILLER_84_577 VGND VGND VPWR VPWR sky130_fd_sc_hd__fill_1
X_4038_ _4039_/A _4458_/A VGND VGND VPWR VPWR _4608_/B sky130_fd_sc_hd__nor2_2
XTAP_TAPCELL_ROW_55_915 VGND VPWR sky130_fd_sc_hd__tapvpwrvgnd_1
XFILLER_112_35 VGND VGND VPWR VPWR sky130_fd_sc_hd__decap_3
XFILLER_112_68 VGND VGND VPWR VPWR sky130_fd_sc_hd__decap_3
XFILLER_25_644 VGND VGND VPWR VPWR sky130_fd_sc_hd__decap_3
XTAP_TAPCELL_ROW_69_1080 VGND VPWR sky130_fd_sc_hd__tapvpwrvgnd_1
XFILLER_24_121 VGND VGND VPWR VPWR sky130_fd_sc_hd__decap_3
XFILLER_24_132 VGND VGND VPWR VPWR sky130_fd_sc_hd__decap_3
XFILLER_52_430 VGND VGND VPWR VPWR sky130_fd_sc_hd__decap_3
XFILLER_52_463 VGND VGND VPWR VPWR sky130_fd_sc_hd__fill_1
XTAP_TAPCELL_ROW_35_672 VGND VPWR sky130_fd_sc_hd__tapvpwrvgnd_1
XFILLER_12_349 VGND VGND VPWR VPWR sky130_fd_sc_hd__decap_3
XFILLER_8_309 VGND VGND VPWR VPWR sky130_fd_sc_hd__decap_3
XFILLER_21_21 VGND VGND VPWR VPWR sky130_fd_sc_hd__decap_3
XFILLER_106_410 VGND VGND VPWR VPWR sky130_fd_sc_hd__fill_1
XFILLER_106_421 VGND VGND VPWR VPWR sky130_fd_sc_hd__decap_3
XFILLER_108_3 VGND VGND VPWR VPWR sky130_fd_sc_hd__decap_3
XFILLER_21_76 VGND VGND VPWR VPWR sky130_fd_sc_hd__decap_3
XFILLER_106_454 VGND VGND VPWR VPWR sky130_fd_sc_hd__decap_3
XFILLER_97_36 VGND VGND VPWR VPWR sky130_fd_sc_hd__fill_1
XFILLER_106_487 VGND VGND VPWR VPWR sky130_fd_sc_hd__decap_3
XFILLER_79_327 VGND VGND VPWR VPWR sky130_fd_sc_hd__fill_1
XFILLER_79_349 VGND VGND VPWR VPWR sky130_fd_sc_hd__decap_3
XTAP_TAPCELL_ROW_7_331 VGND VPWR sky130_fd_sc_hd__tapvpwrvgnd_1
XFILLER_102_660 VGND VGND VPWR VPWR sky130_fd_sc_hd__decap_3
XFILLER_47_202 VGND VGND VPWR VPWR sky130_fd_sc_hd__decap_3
XFILLER_101_192 VGND VGND VPWR VPWR sky130_fd_sc_hd__fill_2
XFILLER_75_544 VGND VGND VPWR VPWR sky130_fd_sc_hd__decap_3
XFILLER_35_408 VGND VGND VPWR VPWR sky130_fd_sc_hd__decap_3
XFILLER_47_279 VGND VGND VPWR VPWR sky130_fd_sc_hd__fill_1
XFILLER_62_205 VGND VGND VPWR VPWR sky130_fd_sc_hd__decap_3
XFILLER_90_536 VGND VGND VPWR VPWR sky130_fd_sc_hd__decap_3
XFILLER_15_121 VGND VGND VPWR VPWR sky130_fd_sc_hd__decap_3
XFILLER_43_430 VGND VGND VPWR VPWR sky130_fd_sc_hd__decap_3
XFILLER_43_452 VGND VGND VPWR VPWR sky130_fd_sc_hd__decap_3
XFILLER_55_290 VGND VGND VPWR VPWR sky130_fd_sc_hd__fill_1
XFILLER_62_249 VGND VGND VPWR VPWR sky130_fd_sc_hd__decap_3
XFILLER_15_154 VGND VGND VPWR VPWR sky130_fd_sc_hd__fill_1
XFILLER_31_603 VGND VGND VPWR VPWR sky130_fd_sc_hd__decap_3
XFILLER_31_614 VGND VGND VPWR VPWR sky130_fd_sc_hd__fill_2
XFILLER_70_271 VGND VGND VPWR VPWR sky130_fd_sc_hd__decap_3
XFILLER_94_9 VGND VGND VPWR VPWR sky130_fd_sc_hd__decap_3
XFILLER_15_198 VGND VGND VPWR VPWR sky130_fd_sc_hd__decap_3
XFILLER_30_168 VGND VGND VPWR VPWR sky130_fd_sc_hd__decap_3
XFILLER_62_83 VGND VGND VPWR VPWR sky130_fd_sc_hd__fill_1
XFILLER_7_12 VGND VGND VPWR VPWR sky130_fd_sc_hd__decap_3
XFILLER_11_393 VGND VGND VPWR VPWR sky130_fd_sc_hd__decap_3
XFILLER_7_45 VGND VGND VPWR VPWR sky130_fd_sc_hd__decap_3
XTAP_TAPCELL_ROW_96_1405 VGND VPWR sky130_fd_sc_hd__tapvpwrvgnd_1
XFILLER_7_364 VGND VGND VPWR VPWR sky130_fd_sc_hd__decap_3
XFILLER_7_78 VGND VGND VPWR VPWR sky130_fd_sc_hd__decap_3
X_3340_ _5129_/A _3340_/B _3340_/C VGND VGND VPWR VPWR _5640_/B sky130_fd_sc_hd__and3_2
XFILLER_112_424 VGND VGND VPWR VPWR sky130_fd_sc_hd__decap_3
XFILLER_3_581 VGND VGND VPWR VPWR sky130_fd_sc_hd__decap_3
XFILLER_98_636 VGND VGND VPWR VPWR sky130_fd_sc_hd__decap_3
XFILLER_85_308 VGND VGND VPWR VPWR sky130_fd_sc_hd__decap_3
XFILLER_97_157 VGND VGND VPWR VPWR sky130_fd_sc_hd__decap_3
X_5010_ _5010_/A _5662_/A _5010_/C _5010_/D VGND VGND VPWR VPWR _5010_/X sky130_fd_sc_hd__or4_2
XFILLER_98_669 VGND VGND VPWR VPWR sky130_fd_sc_hd__decap_3
XFILLER_23_3 VGND VGND VPWR VPWR sky130_fd_sc_hd__decap_3
Xhold1009 _7405_/Q VGND VGND VPWR VPWR _3671_/A1 sky130_fd_sc_hd__dlygate4sd3_1
XFILLER_66_522 VGND VGND VPWR VPWR sky130_fd_sc_hd__fill_2
XFILLER_26_408 VGND VGND VPWR VPWR sky130_fd_sc_hd__decap_3
XFILLER_38_268 VGND VGND VPWR VPWR sky130_fd_sc_hd__fill_1
X_6961_ _6970_/CLK _6961_/D VGND VGND VPWR VPWR _6961_/Q sky130_fd_sc_hd__dfxtp_2
XTAP_TAPCELL_ROW_105_1512 VGND VPWR sky130_fd_sc_hd__tapvpwrvgnd_1
XFILLER_46_290 VGND VGND VPWR VPWR sky130_fd_sc_hd__fill_2
XFILLER_53_249 VGND VGND VPWR VPWR sky130_fd_sc_hd__decap_3
X_6892_ _7005_/CLK _6892_/D VGND VGND VPWR VPWR _6892_/Q sky130_fd_sc_hd__dfxtp_2
XFILLER_21_102 VGND VGND VPWR VPWR sky130_fd_sc_hd__fill_1
XFILLER_21_113 VGND VGND VPWR VPWR sky130_fd_sc_hd__decap_3
XTAP_TAPCELL_ROW_32_631 VGND VPWR sky130_fd_sc_hd__tapvpwrvgnd_1
XTAP_TAPCELL_ROW_60_973 VGND VPWR sky130_fd_sc_hd__tapvpwrvgnd_1
XFILLER_30_691 VGND VGND VPWR VPWR sky130_fd_sc_hd__fill_1
X_4725_ _4969_/B _4720_/X _4723_/X _4724_/X VGND VGND VPWR VPWR _5655_/A sky130_fd_sc_hd__a211o_2
X_7375_ _7387_/CLK _7375_/D _6655_/Y VGND VGND VPWR VPWR _7375_/Q sky130_fd_sc_hd__dfrtp_2
Xhold810 _6739_/Q VGND VGND VPWR VPWR _6739_/D sky130_fd_sc_hd__dlygate4sd3_1
Xhold821 _6843_/Q VGND VGND VPWR VPWR _6843_/D sky130_fd_sc_hd__dlygate4sd3_1
X_4587_ _7287_/Q _4595_/B VGND VGND VPWR VPWR _7287_/D sky130_fd_sc_hd__and2_2
X_3607_ _4295_/B _3607_/B VGND VGND VPWR VPWR _3610_/A sky130_fd_sc_hd__nand2_2
XTAP_TAPCELL_ROW_116_1652 VGND VPWR sky130_fd_sc_hd__tapvpwrvgnd_1
XTAP_TAPCELL_ROW_116_1641 VGND VPWR sky130_fd_sc_hd__tapvpwrvgnd_1
XPHY_EDGE_ROW_2_Left_119 VGND VGND VPWR VPWR sky130_fd_sc_hd__decap_3
XFILLER_115_240 VGND VGND VPWR VPWR sky130_fd_sc_hd__decap_3
XFILLER_89_614 VGND VGND VPWR VPWR sky130_fd_sc_hd__fill_2
Xhold832 _6747_/Q VGND VGND VPWR VPWR _6747_/D sky130_fd_sc_hd__dlygate4sd3_1
Xhold843 _7089_/Q VGND VGND VPWR VPWR _7089_/D sky130_fd_sc_hd__dlygate4sd3_1
Xhold854 _7066_/Q VGND VGND VPWR VPWR _7066_/D sky130_fd_sc_hd__dlygate4sd3_1
Xmax_cap562 _4994_/A2 VGND VGND VPWR VPWR _4275_/A sky130_fd_sc_hd__clkdlybuf4s25_1
X_6326_ _6675_/A VGND VGND VPWR VPWR _6326_/Y sky130_fd_sc_hd__inv_2
X_3538_ _3424_/S _3456_/X _4537_/C _3421_/C VGND VGND VPWR VPWR _3544_/B sky130_fd_sc_hd__o2bb2a_2
XFILLER_107_35 VGND VGND VPWR VPWR sky130_fd_sc_hd__decap_3
XFILLER_107_57 VGND VGND VPWR VPWR sky130_fd_sc_hd__decap_3
XFILLER_115_273 VGND VGND VPWR VPWR sky130_fd_sc_hd__decap_3
XFILLER_115_284 VGND VGND VPWR VPWR sky130_fd_sc_hd__decap_3
XFILLER_88_102 VGND VGND VPWR VPWR sky130_fd_sc_hd__decap_3
XFILLER_89_647 VGND VGND VPWR VPWR sky130_fd_sc_hd__decap_3
Xhold865 _7103_/Q VGND VGND VPWR VPWR _7103_/D sky130_fd_sc_hd__dlygate4sd3_1
Xhold876 _7113_/Q VGND VGND VPWR VPWR _7113_/D sky130_fd_sc_hd__dlygate4sd3_1
Xhold887 _7105_/Q VGND VGND VPWR VPWR _7105_/D sky130_fd_sc_hd__dlygate4sd3_1
Xhold898 _7100_/Q VGND VGND VPWR VPWR _7100_/D sky130_fd_sc_hd__dlygate4sd3_1
Xmax_cap573 _6606_/A VGND VGND VPWR VPWR _6576_/A sky130_fd_sc_hd__buf_2
XFILLER_67_39 VGND VGND VPWR VPWR sky130_fd_sc_hd__decap_3
XFILLER_88_135 VGND VGND VPWR VPWR sky130_fd_sc_hd__decap_3
X_3469_ _3469_/A _3469_/B VGND VGND VPWR VPWR _4537_/C sky130_fd_sc_hd__nor2_2
XFILLER_29_202 VGND VGND VPWR VPWR sky130_fd_sc_hd__decap_3
XTAP_TAPCELL_ROW_4_301 VGND VPWR sky130_fd_sc_hd__tapvpwrvgnd_1
XFILLER_57_522 VGND VGND VPWR VPWR sky130_fd_sc_hd__fill_2
XFILLER_69_393 VGND VGND VPWR VPWR sky130_fd_sc_hd__decap_3
XFILLER_96_190 VGND VGND VPWR VPWR sky130_fd_sc_hd__decap_3
X_5139_ _4677_/B _5138_/X _5139_/B1 VGND VGND VPWR VPWR _5139_/X sky130_fd_sc_hd__o21a_2
XFILLER_97_691 VGND VGND VPWR VPWR sky130_fd_sc_hd__fill_1
XFILLER_29_279 VGND VGND VPWR VPWR sky130_fd_sc_hd__fill_1
XFILLER_57_588 VGND VGND VPWR VPWR sky130_fd_sc_hd__decap_3
XFILLER_44_216 VGND VGND VPWR VPWR sky130_fd_sc_hd__decap_3
XFILLER_84_374 VGND VGND VPWR VPWR sky130_fd_sc_hd__decap_3
XFILLER_16_21 VGND VGND VPWR VPWR sky130_fd_sc_hd__decap_3
XFILLER_16_32 VGND VGND VPWR VPWR sky130_fd_sc_hd__decap_3
XFILLER_44_249 VGND VGND VPWR VPWR sky130_fd_sc_hd__decap_3
XFILLER_16_65 VGND VGND VPWR VPWR sky130_fd_sc_hd__decap_3
XTAP_TAPCELL_ROW_80_1217 VGND VPWR sky130_fd_sc_hd__tapvpwrvgnd_1
XTAP_TAPCELL_ROW_80_1206 VGND VPWR sky130_fd_sc_hd__tapvpwrvgnd_1
XFILLER_12_113 VGND VGND VPWR VPWR sky130_fd_sc_hd__decap_3
XFILLER_12_135 VGND VGND VPWR VPWR sky130_fd_sc_hd__decap_3
XFILLER_13_647 VGND VGND VPWR VPWR sky130_fd_sc_hd__decap_3
XFILLER_16_98 VGND VGND VPWR VPWR sky130_fd_sc_hd__decap_3
XFILLER_40_477 VGND VGND VPWR VPWR sky130_fd_sc_hd__fill_1
XFILLER_8_106 VGND VGND VPWR VPWR sky130_fd_sc_hd__decap_3
XFILLER_32_64 VGND VGND VPWR VPWR sky130_fd_sc_hd__decap_3
XFILLER_8_139 VGND VGND VPWR VPWR sky130_fd_sc_hd__fill_1
XFILLER_20_190 VGND VGND VPWR VPWR sky130_fd_sc_hd__decap_3
XTAP_TAPCELL_ROW_10_369 VGND VPWR sky130_fd_sc_hd__tapvpwrvgnd_1
XFILLER_106_251 VGND VGND VPWR VPWR sky130_fd_sc_hd__fill_1
XFILLER_106_262 VGND VGND VPWR VPWR sky130_fd_sc_hd__decap_3
XFILLER_79_113 VGND VGND VPWR VPWR sky130_fd_sc_hd__decap_3
XTAP_TAPCELL_ROW_91_1346 VGND VPWR sky130_fd_sc_hd__tapvpwrvgnd_1
XFILLER_106_295 VGND VGND VPWR VPWR sky130_fd_sc_hd__decap_3
XFILLER_95_617 VGND VGND VPWR VPWR sky130_fd_sc_hd__decap_3
XFILLER_0_595 VGND VGND VPWR VPWR sky130_fd_sc_hd__decap_3
XFILLER_48_522 VGND VGND VPWR VPWR sky130_fd_sc_hd__fill_2
XFILLER_48_533 VGND VGND VPWR VPWR sky130_fd_sc_hd__decap_3
XFILLER_94_138 VGND VGND VPWR VPWR sky130_fd_sc_hd__fill_2
XFILLER_57_83 VGND VGND VPWR VPWR sky130_fd_sc_hd__decap_3
XFILLER_57_94 VGND VGND VPWR VPWR sky130_fd_sc_hd__decap_3
XFILLER_75_352 VGND VGND VPWR VPWR sky130_fd_sc_hd__decap_3
XFILLER_63_536 VGND VGND VPWR VPWR sky130_fd_sc_hd__decap_3
XFILLER_75_396 VGND VGND VPWR VPWR sky130_fd_sc_hd__decap_3
XFILLER_63_558 VGND VGND VPWR VPWR sky130_fd_sc_hd__fill_2
XFILLER_50_219 VGND VGND VPWR VPWR sky130_fd_sc_hd__decap_3
XFILLER_73_60 VGND VGND VPWR VPWR sky130_fd_sc_hd__fill_2
XTAP_TAPCELL_ROW_18_469 VGND VPWR sky130_fd_sc_hd__tapvpwrvgnd_1
XFILLER_73_93 VGND VGND VPWR VPWR sky130_fd_sc_hd__decap_3
XFILLER_92_6 VGND VGND VPWR VPWR sky130_fd_sc_hd__decap_3
XFILLER_31_455 VGND VGND VPWR VPWR sky130_fd_sc_hd__decap_3
XFILLER_31_477 VGND VGND VPWR VPWR sky130_fd_sc_hd__decap_3
XTAP_TAPCELL_ROW_100_1453 VGND VPWR sky130_fd_sc_hd__tapvpwrvgnd_1
XFILLER_12_680 VGND VGND VPWR VPWR sky130_fd_sc_hd__decap_3
XFILLER_8_662 VGND VGND VPWR VPWR sky130_fd_sc_hd__decap_3
X_4510_ _4510_/A0 _7292_/Q _4510_/S VGND VGND VPWR VPWR _7324_/D sky130_fd_sc_hd__mux2_2
XFILLER_7_161 VGND VGND VPWR VPWR sky130_fd_sc_hd__decap_3
X_4441_ _4813_/B _4441_/B VGND VGND VPWR VPWR _4827_/A sky130_fd_sc_hd__nand2_2
X_7160_ clkload4/A _7160_/D _6440_/Y VGND VGND VPWR VPWR _7160_/Q sky130_fd_sc_hd__dfrtp_2
XPHY_EDGE_ROW_9_Right_9 VGND VGND VPWR VPWR sky130_fd_sc_hd__decap_3
X_4372_ _4372_/A _4627_/A VGND VGND VPWR VPWR _5018_/A sky130_fd_sc_hd__or2_2
XFILLER_98_400 VGND VGND VPWR VPWR sky130_fd_sc_hd__decap_3
XFILLER_112_221 VGND VGND VPWR VPWR sky130_fd_sc_hd__decap_3
XFILLER_86_606 VGND VGND VPWR VPWR sky130_fd_sc_hd__decap_3
X_7091_ clkload5/A _7091_/D _6371_/Y VGND VGND VPWR VPWR _7091_/Q sky130_fd_sc_hd__dfrtp_2
X_3323_ _5129_/A _3519_/B _5294_/A _6979_/Q VGND VGND VPWR VPWR _3323_/X sky130_fd_sc_hd__a31o_2
XFILLER_98_444 VGND VGND VPWR VPWR sky130_fd_sc_hd__decap_3
XFILLER_85_116 VGND VGND VPWR VPWR sky130_fd_sc_hd__decap_3
XFILLER_86_639 VGND VGND VPWR VPWR sky130_fd_sc_hd__decap_3
XTAP_TAPCELL_ROW_111_1582 VGND VPWR sky130_fd_sc_hd__tapvpwrvgnd_1
XPHY_EDGE_ROW_107_Right_107 VGND VGND VPWR VPWR sky130_fd_sc_hd__decap_3
XFILLER_39_544 VGND VGND VPWR VPWR sky130_fd_sc_hd__fill_1
XFILLER_79_691 VGND VGND VPWR VPWR sky130_fd_sc_hd__fill_1
XFILLER_66_341 VGND VGND VPWR VPWR sky130_fd_sc_hd__fill_1
XFILLER_94_672 VGND VGND VPWR VPWR sky130_fd_sc_hd__decap_3
XFILLER_93_160 VGND VGND VPWR VPWR sky130_fd_sc_hd__decap_3
XTAP_TAPCELL_ROW_37_701 VGND VPWR sky130_fd_sc_hd__tapvpwrvgnd_1
XFILLER_19_290 VGND VGND VPWR VPWR sky130_fd_sc_hd__decap_3
XFILLER_26_249 VGND VGND VPWR VPWR sky130_fd_sc_hd__decap_3
XFILLER_54_558 VGND VGND VPWR VPWR sky130_fd_sc_hd__decap_3
XFILLER_81_344 VGND VGND VPWR VPWR sky130_fd_sc_hd__decap_3
X_6944_ _6944_/CLK _6944_/D VGND VGND VPWR VPWR _6944_/Q sky130_fd_sc_hd__dfxtp_2
XFILLER_22_411 VGND VGND VPWR VPWR sky130_fd_sc_hd__decap_3
X_6875_ _7386_/CLK _6875_/D VGND VGND VPWR VPWR _6875_/Q sky130_fd_sc_hd__dfxtp_2
XFILLER_22_455 VGND VGND VPWR VPWR sky130_fd_sc_hd__fill_2
XFILLER_22_466 VGND VGND VPWR VPWR sky130_fd_sc_hd__decap_3
XFILLER_22_477 VGND VGND VPWR VPWR sky130_fd_sc_hd__decap_3
XFILLER_10_639 VGND VGND VPWR VPWR sky130_fd_sc_hd__decap_3
X_4708_ _7001_/Q _4825_/B VGND VGND VPWR VPWR _4826_/A sky130_fd_sc_hd__and2_2
X_5688_ _7350_/Q hold952/X _5708_/S VGND VGND VPWR VPWR _6694_/D sky130_fd_sc_hd__mux2_2
X_4639_ _4639_/A _4948_/B VGND VGND VPWR VPWR _4918_/A sky130_fd_sc_hd__or2_2
X_7358_ _7360_/CLK _7358_/D _6638_/Y VGND VGND VPWR VPWR _7358_/Q sky130_fd_sc_hd__dfrtp_2
Xhold640 _6810_/Q VGND VGND VPWR VPWR _6810_/D sky130_fd_sc_hd__dlygate4sd3_1
Xhold651 _6761_/Q VGND VGND VPWR VPWR _6761_/D sky130_fd_sc_hd__dlygate4sd3_1
Xhold662 _6722_/Q VGND VGND VPWR VPWR _6722_/D sky130_fd_sc_hd__dlygate4sd3_1
XFILLER_89_433 VGND VGND VPWR VPWR sky130_fd_sc_hd__decap_3
X_7289_ _7360_/CLK _7289_/D _6569_/Y VGND VGND VPWR VPWR _7289_/Q sky130_fd_sc_hd__dfrtp_2
Xhold673 _6813_/Q VGND VGND VPWR VPWR _6813_/D sky130_fd_sc_hd__dlygate4sd3_1
Xhold684 _6943_/Q VGND VGND VPWR VPWR _6943_/D sky130_fd_sc_hd__dlygate4sd3_1
Xhold695 _6774_/Q VGND VGND VPWR VPWR _6774_/D sky130_fd_sc_hd__dlygate4sd3_1
X_6309_ _6672_/A VGND VGND VPWR VPWR _6309_/Y sky130_fd_sc_hd__inv_2
XFILLER_49_319 VGND VGND VPWR VPWR sky130_fd_sc_hd__decap_3
XFILLER_77_617 VGND VGND VPWR VPWR sky130_fd_sc_hd__fill_1
XFILLER_77_639 VGND VGND VPWR VPWR sky130_fd_sc_hd__decap_3
XFILLER_89_477 VGND VGND VPWR VPWR sky130_fd_sc_hd__decap_3
XFILLER_103_287 VGND VGND VPWR VPWR sky130_fd_sc_hd__decap_3
XFILLER_94_15 VGND VGND VPWR VPWR sky130_fd_sc_hd__decap_3
XFILLER_45_503 VGND VGND VPWR VPWR sky130_fd_sc_hd__fill_1
XFILLER_57_352 VGND VGND VPWR VPWR sky130_fd_sc_hd__decap_3
XFILLER_69_190 VGND VGND VPWR VPWR sky130_fd_sc_hd__decap_3
XFILLER_85_650 VGND VGND VPWR VPWR sky130_fd_sc_hd__decap_3
XFILLER_94_37 VGND VGND VPWR VPWR sky130_fd_sc_hd__decap_3
XFILLER_17_216 VGND VGND VPWR VPWR sky130_fd_sc_hd__decap_3
XFILLER_27_42 VGND VGND VPWR VPWR sky130_fd_sc_hd__decap_3
XFILLER_57_385 VGND VGND VPWR VPWR sky130_fd_sc_hd__fill_1
XFILLER_84_171 VGND VGND VPWR VPWR sky130_fd_sc_hd__decap_3
XFILLER_91_119 VGND VGND VPWR VPWR sky130_fd_sc_hd__decap_3
XFILLER_17_249 VGND VGND VPWR VPWR sky130_fd_sc_hd__decap_3
XFILLER_27_75 VGND VGND VPWR VPWR sky130_fd_sc_hd__decap_3
XFILLER_72_333 VGND VGND VPWR VPWR sky130_fd_sc_hd__decap_3
XFILLER_72_399 VGND VGND VPWR VPWR sky130_fd_sc_hd__decap_3
XTAP_TAPCELL_ROW_15_428 VGND VPWR sky130_fd_sc_hd__tapvpwrvgnd_1
XFILLER_13_499 VGND VGND VPWR VPWR sky130_fd_sc_hd__decap_3
XFILLER_43_96 VGND VGND VPWR VPWR sky130_fd_sc_hd__decap_3
XFILLER_5_665 VGND VGND VPWR VPWR sky130_fd_sc_hd__decap_3
XFILLER_4_153 VGND VGND VPWR VPWR sky130_fd_sc_hd__decap_3
XFILLER_4_24 VGND VGND VPWR VPWR sky130_fd_sc_hd__decap_3
XFILLER_5_676 VGND VGND VPWR VPWR sky130_fd_sc_hd__decap_3
XFILLER_4_197 VGND VGND VPWR VPWR sky130_fd_sc_hd__fill_1
XFILLER_4_35 VGND VGND VPWR VPWR sky130_fd_sc_hd__decap_3
XFILLER_4_68 VGND VGND VPWR VPWR sky130_fd_sc_hd__decap_3
XFILLER_68_71 VGND VGND VPWR VPWR sky130_fd_sc_hd__decap_3
XFILLER_95_414 VGND VGND VPWR VPWR sky130_fd_sc_hd__decap_3
XFILLER_67_116 VGND VGND VPWR VPWR sky130_fd_sc_hd__fill_1
XFILLER_67_149 VGND VGND VPWR VPWR sky130_fd_sc_hd__decap_3
XFILLER_95_458 VGND VGND VPWR VPWR sky130_fd_sc_hd__fill_2
XFILLER_75_160 VGND VGND VPWR VPWR sky130_fd_sc_hd__decap_3
XFILLER_76_672 VGND VGND VPWR VPWR sky130_fd_sc_hd__decap_3
XFILLER_91_620 VGND VGND VPWR VPWR sky130_fd_sc_hd__decap_3
XFILLER_90_130 VGND VGND VPWR VPWR sky130_fd_sc_hd__fill_1
XFILLER_90_141 VGND VGND VPWR VPWR sky130_fd_sc_hd__decap_3
XFILLER_91_653 VGND VGND VPWR VPWR sky130_fd_sc_hd__decap_3
Xplace322 _4341_/A2 VGND VGND VPWR VPWR _4601_/S sky130_fd_sc_hd__buf_2
Xplace311 _4577_/B VGND VGND VPWR VPWR _4571_/B sky130_fd_sc_hd__buf_2
Xplace300 _4361_/A VGND VGND VPWR VPWR _5086_/A sky130_fd_sc_hd__buf_2
XFILLER_23_208 VGND VGND VPWR VPWR sky130_fd_sc_hd__decap_3
XFILLER_90_174 VGND VGND VPWR VPWR sky130_fd_sc_hd__decap_3
Xplace355 _4417_/A2 VGND VGND VPWR VPWR _4901_/S sky130_fd_sc_hd__buf_2
Xplace344 _3618_/C VGND VGND VPWR VPWR _4764_/B sky130_fd_sc_hd__buf_2
Xplace333 _3407_/X VGND VGND VPWR VPWR _4351_/B1 sky130_fd_sc_hd__buf_2
X_4990_ _4620_/A _4989_/X _4374_/X VGND VGND VPWR VPWR _5004_/B sky130_fd_sc_hd__o21ai_2
XFILLER_51_539 VGND VGND VPWR VPWR sky130_fd_sc_hd__decap_3
Xplace388 _4671_/B VGND VGND VPWR VPWR _5622_/B sky130_fd_sc_hd__buf_2
Xplace377 _5104_/A VGND VGND VPWR VPWR _4466_/A sky130_fd_sc_hd__buf_2
Xplace366 _4248_/A VGND VGND VPWR VPWR _4429_/C1 sky130_fd_sc_hd__buf_2
X_3941_ _7369_/Q _4484_/A0 _3945_/S VGND VGND VPWR VPWR _7369_/D sky130_fd_sc_hd__mux2_2
XFILLER_31_252 VGND VGND VPWR VPWR sky130_fd_sc_hd__decap_3
Xplace399 _4503_/S VGND VGND VPWR VPWR _4510_/S sky130_fd_sc_hd__buf_2
X_6660_ _6660_/A VGND VGND VPWR VPWR _6660_/Y sky130_fd_sc_hd__inv_2
X_3872_ _6921_/Q _3906_/A2 _5660_/B _6695_/Q _3871_/X VGND VGND VPWR VPWR _3872_/X
+ sky130_fd_sc_hd__a221o_2
X_6591_ _6634_/A VGND VGND VPWR VPWR _6591_/Y sky130_fd_sc_hd__inv_2
X_5611_ _5611_/A _5634_/B VGND VGND VPWR VPWR _7022_/D sky130_fd_sc_hd__and2_2
XFILLER_105_519 VGND VGND VPWR VPWR sky130_fd_sc_hd__decap_3
X_7212_ _7310_/CLK _7212_/D _6492_/Y VGND VGND VPWR VPWR _7212_/Q sky130_fd_sc_hd__dfrtp_2
X_4424_ _4425_/A _4425_/C _4649_/B VGND VGND VPWR VPWR _4446_/A sky130_fd_sc_hd__a21oi_2
XTAP_TAPCELL_ROW_113_1611 VGND VPWR sky130_fd_sc_hd__tapvpwrvgnd_1
XFILLER_113_541 VGND VGND VPWR VPWR sky130_fd_sc_hd__decap_3
X_7143_ _7337_/CLK _7143_/D _6423_/Y VGND VGND VPWR VPWR _7143_/Q sky130_fd_sc_hd__dfrtp_2
X_4355_ _4355_/A _4355_/B VGND VGND VPWR VPWR _4355_/X sky130_fd_sc_hd__or2_2
XPHY_EDGE_ROW_92_Left_209 VGND VGND VPWR VPWR sky130_fd_sc_hd__decap_3
XFILLER_59_617 VGND VGND VPWR VPWR sky130_fd_sc_hd__decap_3
X_7074_ _7265_/CLK _7074_/D _6354_/Y VGND VGND VPWR VPWR _7074_/Q sky130_fd_sc_hd__dfrtp_2
X_3306_ _5129_/A _3328_/A _6981_/D _4696_/B _3340_/B VGND VGND VPWR VPWR _3378_/A
+ sky130_fd_sc_hd__o221a_2
XFILLER_100_235 VGND VGND VPWR VPWR sky130_fd_sc_hd__decap_3
XFILLER_113_585 VGND VGND VPWR VPWR sky130_fd_sc_hd__decap_3
XFILLER_58_138 VGND VGND VPWR VPWR sky130_fd_sc_hd__fill_2
X_4286_ _4286_/A _4286_/B VGND VGND VPWR VPWR _4288_/C sky130_fd_sc_hd__or2_2
XFILLER_98_296 VGND VGND VPWR VPWR sky130_fd_sc_hd__decap_3
XFILLER_67_650 VGND VGND VPWR VPWR sky130_fd_sc_hd__decap_3
XFILLER_73_108 VGND VGND VPWR VPWR sky130_fd_sc_hd__fill_1
XFILLER_100_279 VGND VGND VPWR VPWR sky130_fd_sc_hd__decap_3
XFILLER_64_18 VGND VGND VPWR VPWR sky130_fd_sc_hd__decap_3
XFILLER_66_171 VGND VGND VPWR VPWR sky130_fd_sc_hd__decap_3
XFILLER_82_631 VGND VGND VPWR VPWR sky130_fd_sc_hd__decap_3
XFILLER_42_528 VGND VGND VPWR VPWR sky130_fd_sc_hd__decap_3
XFILLER_81_152 VGND VGND VPWR VPWR sky130_fd_sc_hd__decap_3
XFILLER_82_675 VGND VGND VPWR VPWR sky130_fd_sc_hd__decap_3
X_6927_ _7392_/CLK _6927_/D VGND VGND VPWR VPWR _6927_/Q sky130_fd_sc_hd__dfxtp_2
XFILLER_80_39 VGND VGND VPWR VPWR sky130_fd_sc_hd__decap_3
Xfanout23 _6570_/A VGND VGND VPWR VPWR _6532_/A sky130_fd_sc_hd__buf_2
Xfanout34 fanout38/X VGND VGND VPWR VPWR _6637_/A sky130_fd_sc_hd__buf_2
Xfanout45 _6643_/A VGND VGND VPWR VPWR _6611_/A sky130_fd_sc_hd__buf_2
Xfanout56 _6686_/A VGND VGND VPWR VPWR _6684_/A sky130_fd_sc_hd__buf_2
X_6858_ _6909_/CLK _6858_/D VGND VGND VPWR VPWR _6858_/Q sky130_fd_sc_hd__dfxtp_2
XFILLER_13_11 VGND VGND VPWR VPWR sky130_fd_sc_hd__decap_3
XFILLER_22_285 VGND VGND VPWR VPWR sky130_fd_sc_hd__decap_3
Xfanout67 _6619_/A VGND VGND VPWR VPWR _6558_/A sky130_fd_sc_hd__clkdlybuf4s25_1
XTAP_TAPCELL_ROW_40_729 VGND VPWR sky130_fd_sc_hd__tapvpwrvgnd_1
XFILLER_13_44 VGND VGND VPWR VPWR sky130_fd_sc_hd__decap_3
XFILLER_13_66 VGND VGND VPWR VPWR sky130_fd_sc_hd__decap_3
X_6789_ _6975_/CLK _6789_/D VGND VGND VPWR VPWR _6789_/Q sky130_fd_sc_hd__dfxtp_2
XFILLER_108_313 VGND VGND VPWR VPWR sky130_fd_sc_hd__decap_3
XFILLER_108_335 VGND VGND VPWR VPWR sky130_fd_sc_hd__decap_3
XFILLER_89_15 VGND VGND VPWR VPWR sky130_fd_sc_hd__decap_3
XTAP_TAPCELL_ROW_20_497 VGND VPWR sky130_fd_sc_hd__tapvpwrvgnd_1
XTAP_TAPCELL_ROW_20_486 VGND VPWR sky130_fd_sc_hd__tapvpwrvgnd_1
XFILLER_108_379 VGND VGND VPWR VPWR sky130_fd_sc_hd__decap_3
XFILLER_2_624 VGND VGND VPWR VPWR sky130_fd_sc_hd__decap_3
XTAP_TAPCELL_ROW_75_1149 VGND VPWR sky130_fd_sc_hd__tapvpwrvgnd_1
XFILLER_104_541 VGND VGND VPWR VPWR sky130_fd_sc_hd__decap_3
XFILLER_1_134 VGND VGND VPWR VPWR sky130_fd_sc_hd__decap_3
XFILLER_2_657 VGND VGND VPWR VPWR sky130_fd_sc_hd__decap_3
XFILLER_1_167 VGND VGND VPWR VPWR sky130_fd_sc_hd__fill_1
XFILLER_89_252 VGND VGND VPWR VPWR sky130_fd_sc_hd__fill_1
XFILLER_89_263 VGND VGND VPWR VPWR sky130_fd_sc_hd__decap_3
XFILLER_1_178 VGND VGND VPWR VPWR sky130_fd_sc_hd__fill_1
XFILLER_49_116 VGND VGND VPWR VPWR sky130_fd_sc_hd__decap_3
XFILLER_77_447 VGND VGND VPWR VPWR sky130_fd_sc_hd__fill_1
XFILLER_38_63 VGND VGND VPWR VPWR sky130_fd_sc_hd__decap_3
XFILLER_65_609 VGND VGND VPWR VPWR sky130_fd_sc_hd__decap_3
XFILLER_77_458 VGND VGND VPWR VPWR sky130_fd_sc_hd__decap_3
XFILLER_38_85 VGND VGND VPWR VPWR sky130_fd_sc_hd__fill_2
XFILLER_38_96 VGND VGND VPWR VPWR sky130_fd_sc_hd__decap_3
XFILLER_58_672 VGND VGND VPWR VPWR sky130_fd_sc_hd__decap_3
XFILLER_64_108 VGND VGND VPWR VPWR sky130_fd_sc_hd__decap_3
XFILLER_92_439 VGND VGND VPWR VPWR sky130_fd_sc_hd__decap_3
Xhold1170 _7167_/Q VGND VGND VPWR VPWR _5327_/A0 sky130_fd_sc_hd__dlygate4sd3_1
XTAP_TAPCELL_ROW_48_829 VGND VPWR sky130_fd_sc_hd__tapvpwrvgnd_1
XFILLER_57_182 VGND VGND VPWR VPWR sky130_fd_sc_hd__fill_2
XFILLER_72_130 VGND VGND VPWR VPWR sky130_fd_sc_hd__decap_3
XFILLER_73_653 VGND VGND VPWR VPWR sky130_fd_sc_hd__decap_3
Xhold1181 _7249_/Q VGND VGND VPWR VPWR _5142_/A0 sky130_fd_sc_hd__dlygate4sd3_1
Xhold1192 _7011_/Q VGND VGND VPWR VPWR _5634_/A sky130_fd_sc_hd__dlygate4sd3_1
XFILLER_45_366 VGND VGND VPWR VPWR sky130_fd_sc_hd__decap_3
XTAP_TAPCELL_ROW_86_1289 VGND VPWR sky130_fd_sc_hd__tapvpwrvgnd_1
XTAP_TAPCELL_ROW_86_1278 VGND VPWR sky130_fd_sc_hd__tapvpwrvgnd_1
XFILLER_45_399 VGND VGND VPWR VPWR sky130_fd_sc_hd__decap_3
XFILLER_54_62 VGND VGND VPWR VPWR sky130_fd_sc_hd__decap_3
XFILLER_72_174 VGND VGND VPWR VPWR sky130_fd_sc_hd__decap_3
XTAP_TAPCELL_ROW_28_586 VGND VPWR sky130_fd_sc_hd__tapvpwrvgnd_1
XFILLER_13_252 VGND VGND VPWR VPWR sky130_fd_sc_hd__fill_1
XFILLER_41_561 VGND VGND VPWR VPWR sky130_fd_sc_hd__decap_3
XFILLER_41_594 VGND VGND VPWR VPWR sky130_fd_sc_hd__fill_1
XFILLER_13_296 VGND VGND VPWR VPWR sky130_fd_sc_hd__decap_3
XFILLER_70_61 VGND VGND VPWR VPWR sky130_fd_sc_hd__decap_3
XFILLER_9_256 VGND VGND VPWR VPWR sky130_fd_sc_hd__decap_3
Xclkload15 _6972_/CLK VGND VGND VPWR VPWR clkload15/Y sky130_fd_sc_hd__bufinv_16
Xclkload26 _7397_/CLK VGND VGND VPWR VPWR clkload26/Y sky130_fd_sc_hd__bufinv_16
XFILLER_114_327 VGND VGND VPWR VPWR sky130_fd_sc_hd__decap_3
XFILLER_55_6 VGND VGND VPWR VPWR sky130_fd_sc_hd__decap_3
XFILLER_79_81 VGND VGND VPWR VPWR sky130_fd_sc_hd__decap_3
X_4140_ _4117_/Y _4124_/B _4890_/B _4886_/A VGND VGND VPWR VPWR _4140_/X sky130_fd_sc_hd__a2bb2o_2
XFILLER_110_533 VGND VGND VPWR VPWR sky130_fd_sc_hd__fill_1
XFILLER_68_447 VGND VGND VPWR VPWR sky130_fd_sc_hd__decap_3
XFILLER_110_566 VGND VGND VPWR VPWR sky130_fd_sc_hd__decap_3
XFILLER_49_650 VGND VGND VPWR VPWR sky130_fd_sc_hd__decap_3
XFILLER_68_469 VGND VGND VPWR VPWR sky130_fd_sc_hd__decap_3
X_4071_ _7307_/Q _4482_/S _4437_/B1 _7371_/Q _4429_/C1 VGND VGND VPWR VPWR _4071_/X
+ sky130_fd_sc_hd__a221o_2
XFILLER_48_160 VGND VGND VPWR VPWR sky130_fd_sc_hd__fill_2
XFILLER_55_108 VGND VGND VPWR VPWR sky130_fd_sc_hd__decap_3
XFILLER_95_288 VGND VGND VPWR VPWR sky130_fd_sc_hd__decap_3
XFILLER_95_80 VGND VGND VPWR VPWR sky130_fd_sc_hd__decap_3
XFILLER_64_631 VGND VGND VPWR VPWR sky130_fd_sc_hd__decap_3
XFILLER_64_675 VGND VGND VPWR VPWR sky130_fd_sc_hd__decap_3
XFILLER_63_174 VGND VGND VPWR VPWR sky130_fd_sc_hd__decap_3
XFILLER_63_196 VGND VGND VPWR VPWR sky130_fd_sc_hd__decap_3
X_4973_ _5595_/B _4973_/B _3813_/Y VGND VGND VPWR VPWR _4973_/X sky130_fd_sc_hd__or3b_2
XFILLER_51_358 VGND VGND VPWR VPWR sky130_fd_sc_hd__decap_3
X_6712_ _7405_/CLK _6712_/D VGND VGND VPWR VPWR _6712_/Q sky130_fd_sc_hd__dfxtp_2
X_3924_ _3924_/A1 _3864_/S _3923_/X VGND VGND VPWR VPWR _7376_/D sky130_fd_sc_hd__o21a_2
X_6643_ _6643_/A VGND VGND VPWR VPWR _6643_/Y sky130_fd_sc_hd__inv_2
Xclkload9 clkload9/A VGND VGND VPWR VPWR clkload9/X sky130_fd_sc_hd__clkbuf_1
X_3855_ _3728_/Y _3847_/X _3849_/X _3714_/X _3854_/X VGND VGND VPWR VPWR _3855_/X
+ sky130_fd_sc_hd__a221o_2
X_6574_ _6604_/A VGND VGND VPWR VPWR _6574_/Y sky130_fd_sc_hd__inv_2
X_3786_ _6751_/Q _3661_/X _3656_/Y _6733_/Q VGND VGND VPWR VPWR _3786_/X sky130_fd_sc_hd__a22o_2
XFILLER_105_316 VGND VGND VPWR VPWR sky130_fd_sc_hd__fill_2
XFILLER_105_327 VGND VGND VPWR VPWR sky130_fd_sc_hd__fill_2
Xoutput520 _5362_/C VGND VGND VPWR VPWR instruction_out[8] sky130_fd_sc_hd__clkdlybuf4s25_1
XFILLER_59_18 VGND VGND VPWR VPWR sky130_fd_sc_hd__decap_3
Xoutput553 _6986_/Q VGND VGND VPWR VPWR pc_out[9] sky130_fd_sc_hd__clkdlybuf4s25_1
Xoutput542 _7005_/Q VGND VGND VPWR VPWR pc_out[28] sky130_fd_sc_hd__clkdlybuf4s25_1
Xoutput531 _6995_/Q VGND VGND VPWR VPWR pc_out[18] sky130_fd_sc_hd__clkdlybuf4s25_1
X_4407_ _7370_/Q _4435_/B1 _4436_/B1 _7178_/Q _4406_/X VGND VGND VPWR VPWR _4407_/X
+ sky130_fd_sc_hd__a221o_2
XFILLER_99_572 VGND VGND VPWR VPWR sky130_fd_sc_hd__decap_3
XFILLER_101_511 VGND VGND VPWR VPWR sky130_fd_sc_hd__fill_2
XFILLER_113_360 VGND VGND VPWR VPWR sky130_fd_sc_hd__decap_3
XFILLER_113_393 VGND VGND VPWR VPWR sky130_fd_sc_hd__decap_3
XFILLER_115_35 VGND VGND VPWR VPWR sky130_fd_sc_hd__decap_3
XFILLER_86_200 VGND VGND VPWR VPWR sky130_fd_sc_hd__decap_3
X_7126_ clkload5/A _7126_/D _6406_/Y VGND VGND VPWR VPWR _7126_/Q sky130_fd_sc_hd__dfrtp_2
X_4338_ _7319_/Q _3977_/S _4338_/B1 _7351_/Q _3556_/A VGND VGND VPWR VPWR _4338_/X
+ sky130_fd_sc_hd__a221o_2
XFILLER_115_57 VGND VGND VPWR VPWR sky130_fd_sc_hd__decap_3
XFILLER_86_244 VGND VGND VPWR VPWR sky130_fd_sc_hd__fill_2
X_7057_ clkload4/A _7057_/D _6337_/Y VGND VGND VPWR VPWR _7057_/Q sky130_fd_sc_hd__dfrtp_2
X_4269_ _7230_/Q _4469_/A3 _4510_/S _7043_/Q _4268_/X VGND VGND VPWR VPWR _4271_/C
+ sky130_fd_sc_hd__a221o_2
XFILLER_101_577 VGND VGND VPWR VPWR sky130_fd_sc_hd__fill_2
XFILLER_27_311 VGND VGND VPWR VPWR sky130_fd_sc_hd__decap_3
XFILLER_39_160 VGND VGND VPWR VPWR sky130_fd_sc_hd__decap_3
XFILLER_55_620 VGND VGND VPWR VPWR sky130_fd_sc_hd__decap_3
XFILLER_55_653 VGND VGND VPWR VPWR sky130_fd_sc_hd__decap_3
XFILLER_42_303 VGND VGND VPWR VPWR sky130_fd_sc_hd__decap_3
XFILLER_54_141 VGND VGND VPWR VPWR sky130_fd_sc_hd__decap_3
XFILLER_70_601 VGND VGND VPWR VPWR sky130_fd_sc_hd__decap_3
XFILLER_54_174 VGND VGND VPWR VPWR sky130_fd_sc_hd__decap_3
XFILLER_70_634 VGND VGND VPWR VPWR sky130_fd_sc_hd__decap_3
XFILLER_70_645 VGND VGND VPWR VPWR sky130_fd_sc_hd__decap_3
XFILLER_42_347 VGND VGND VPWR VPWR sky130_fd_sc_hd__decap_3
XFILLER_70_678 VGND VGND VPWR VPWR sky130_fd_sc_hd__decap_3
XTAP_TAPCELL_ROW_25_556 VGND VPWR sky130_fd_sc_hd__tapvpwrvgnd_1
XFILLER_10_200 VGND VGND VPWR VPWR sky130_fd_sc_hd__decap_3
XFILLER_23_561 VGND VGND VPWR VPWR sky130_fd_sc_hd__decap_3
XFILLER_24_76 VGND VGND VPWR VPWR sky130_fd_sc_hd__decap_3
XTAP_TAPCELL_ROW_53_887 VGND VPWR sky130_fd_sc_hd__tapvpwrvgnd_1
XFILLER_109_600 VGND VGND VPWR VPWR sky130_fd_sc_hd__decap_3
XFILLER_108_121 VGND VGND VPWR VPWR sky130_fd_sc_hd__decap_3
XFILLER_109_644 VGND VGND VPWR VPWR sky130_fd_sc_hd__decap_3
XFILLER_6_237 VGND VGND VPWR VPWR sky130_fd_sc_hd__fill_1
XFILLER_109_688 VGND VGND VPWR VPWR sky130_fd_sc_hd__decap_3
XFILLER_2_410 VGND VGND VPWR VPWR sky130_fd_sc_hd__decap_3
XFILLER_2_421 VGND VGND VPWR VPWR sky130_fd_sc_hd__decap_3
XFILLER_2_454 VGND VGND VPWR VPWR sky130_fd_sc_hd__decap_3
XFILLER_104_371 VGND VGND VPWR VPWR sky130_fd_sc_hd__decap_3
XFILLER_1_14 VGND VGND VPWR VPWR sky130_fd_sc_hd__decap_3
XFILLER_1_47 VGND VGND VPWR VPWR sky130_fd_sc_hd__decap_3
XFILLER_77_266 VGND VGND VPWR VPWR sky130_fd_sc_hd__decap_3
XFILLER_92_203 VGND VGND VPWR VPWR sky130_fd_sc_hd__fill_1
XTAP_TAPCELL_ROW_88_1307 VGND VPWR sky130_fd_sc_hd__tapvpwrvgnd_1
XFILLER_18_333 VGND VGND VPWR VPWR sky130_fd_sc_hd__decap_3
XFILLER_1_69 VGND VGND VPWR VPWR sky130_fd_sc_hd__decap_3
XFILLER_46_620 VGND VGND VPWR VPWR sky130_fd_sc_hd__decap_3
XFILLER_58_480 VGND VGND VPWR VPWR sky130_fd_sc_hd__decap_3
XFILLER_92_247 VGND VGND VPWR VPWR sky130_fd_sc_hd__decap_3
XFILLER_46_675 VGND VGND VPWR VPWR sky130_fd_sc_hd__decap_3
XFILLER_65_72 VGND VGND VPWR VPWR sky130_fd_sc_hd__decap_3
XFILLER_60_111 VGND VGND VPWR VPWR sky130_fd_sc_hd__decap_3
XFILLER_61_623 VGND VGND VPWR VPWR sky130_fd_sc_hd__decap_3
XFILLER_61_656 VGND VGND VPWR VPWR sky130_fd_sc_hd__decap_3
XFILLER_14_561 VGND VGND VPWR VPWR sky130_fd_sc_hd__decap_3
XFILLER_60_177 VGND VGND VPWR VPWR sky130_fd_sc_hd__decap_3
XFILLER_81_82 VGND VGND VPWR VPWR sky130_fd_sc_hd__fill_1
XTAP_TAPCELL_ROW_99_1436 VGND VPWR sky130_fd_sc_hd__tapvpwrvgnd_1
X_3640_ _3635_/X _3637_/X _3639_/X VGND VGND VPWR VPWR _3640_/X sky130_fd_sc_hd__o21ba_2
X_3571_ _3326_/A _3424_/S _5648_/B _3569_/X _3570_/X VGND VGND VPWR VPWR _3607_/B
+ sky130_fd_sc_hd__o32a_2
XFILLER_115_603 VGND VGND VPWR VPWR sky130_fd_sc_hd__decap_3
XFILLER_53_3 VGND VGND VPWR VPWR sky130_fd_sc_hd__decap_3
X_6290_ _6388_/A VGND VGND VPWR VPWR _6290_/Y sky130_fd_sc_hd__inv_2
X_5310_ _5310_/A0 _4836_/X _5315_/S VGND VGND VPWR VPWR _7175_/D sky130_fd_sc_hd__mux2_2
XFILLER_114_124 VGND VGND VPWR VPWR sky130_fd_sc_hd__decap_3
XFILLER_115_647 VGND VGND VPWR VPWR sky130_fd_sc_hd__decap_3
XFILLER_114_168 VGND VGND VPWR VPWR sky130_fd_sc_hd__decap_3
X_5241_ _5241_/A0 _4806_/X _5245_/S VGND VGND VPWR VPWR _7209_/D sky130_fd_sc_hd__mux2_2
XFILLER_68_200 VGND VGND VPWR VPWR sky130_fd_sc_hd__decap_3
XFILLER_96_531 VGND VGND VPWR VPWR sky130_fd_sc_hd__fill_1
XFILLER_110_341 VGND VGND VPWR VPWR sky130_fd_sc_hd__decap_3
XFILLER_96_542 VGND VGND VPWR VPWR sky130_fd_sc_hd__decap_3
X_4123_ _4119_/X _4122_/X _4327_/A VGND VGND VPWR VPWR _4124_/B sky130_fd_sc_hd__o21a_2
XFILLER_110_374 VGND VGND VPWR VPWR sky130_fd_sc_hd__decap_3
X_4054_ _4054_/A _4456_/A VGND VGND VPWR VPWR _4658_/A sky130_fd_sc_hd__nand2_2
XFILLER_49_480 VGND VGND VPWR VPWR sky130_fd_sc_hd__decap_3
XFILLER_36_152 VGND VGND VPWR VPWR sky130_fd_sc_hd__decap_3
XFILLER_52_601 VGND VGND VPWR VPWR sky130_fd_sc_hd__decap_3
XTAP_TAPCELL_ROW_108_1543 VGND VPWR sky130_fd_sc_hd__tapvpwrvgnd_1
XFILLER_52_634 VGND VGND VPWR VPWR sky130_fd_sc_hd__decap_3
XFILLER_52_645 VGND VGND VPWR VPWR sky130_fd_sc_hd__decap_3
XFILLER_64_472 VGND VGND VPWR VPWR sky130_fd_sc_hd__decap_3
XFILLER_101_26 VGND VGND VPWR VPWR sky130_fd_sc_hd__decap_3
XFILLER_51_122 VGND VGND VPWR VPWR sky130_fd_sc_hd__fill_2
XFILLER_52_678 VGND VGND VPWR VPWR sky130_fd_sc_hd__decap_3
XFILLER_51_188 VGND VGND VPWR VPWR sky130_fd_sc_hd__decap_3
X_4956_ _4948_/Y _4951_/Y _4954_/X _4955_/X VGND VGND VPWR VPWR _5662_/C sky130_fd_sc_hd__a211o_2
XTAP_TAPCELL_ROW_22_515 VGND VPWR sky130_fd_sc_hd__tapvpwrvgnd_1
X_4887_ _4886_/A _4890_/B _4814_/A VGND VGND VPWR VPWR _4887_/Y sky130_fd_sc_hd__a21oi_2
X_3907_ _6781_/Q _3907_/A2 _3917_/B1 _6869_/Q _3906_/X VGND VGND VPWR VPWR _3907_/X
+ sky130_fd_sc_hd__a221o_2
XTAP_TAPCELL_ROW_50_857 VGND VPWR sky130_fd_sc_hd__tapvpwrvgnd_1
XTAP_TAPCELL_ROW_50_846 VGND VPWR sky130_fd_sc_hd__tapvpwrvgnd_1
XFILLER_20_575 VGND VGND VPWR VPWR sky130_fd_sc_hd__fill_1
X_6626_ _6664_/A VGND VGND VPWR VPWR _6626_/Y sky130_fd_sc_hd__inv_2
X_3838_ _6773_/Q _3886_/A2 _3886_/B1 _6761_/Q _3837_/X VGND VGND VPWR VPWR _3838_/X
+ sky130_fd_sc_hd__a221o_2
X_6557_ _6647_/A VGND VGND VPWR VPWR _6557_/Y sky130_fd_sc_hd__inv_2
XFILLER_106_603 VGND VGND VPWR VPWR sky130_fd_sc_hd__decap_3
XFILLER_10_12 VGND VGND VPWR VPWR sky130_fd_sc_hd__decap_3
X_3769_ _3746_/C _3767_/X _3768_/X _4799_/A VGND VGND VPWR VPWR _4944_/B sky130_fd_sc_hd__o31a_2
XFILLER_105_102 VGND VGND VPWR VPWR sky130_fd_sc_hd__decap_3
XFILLER_105_113 VGND VGND VPWR VPWR sky130_fd_sc_hd__decap_3
XFILLER_106_636 VGND VGND VPWR VPWR sky130_fd_sc_hd__decap_3
X_6488_ _6675_/A VGND VGND VPWR VPWR _6488_/Y sky130_fd_sc_hd__inv_2
XFILLER_106_669 VGND VGND VPWR VPWR sky130_fd_sc_hd__decap_3
XFILLER_10_56 VGND VGND VPWR VPWR sky130_fd_sc_hd__decap_3
XTAP_TAPCELL_ROW_72_1119 VGND VPWR sky130_fd_sc_hd__tapvpwrvgnd_1
XFILLER_113_190 VGND VGND VPWR VPWR sky130_fd_sc_hd__decap_3
XFILLER_59_233 VGND VGND VPWR VPWR sky130_fd_sc_hd__decap_3
X_7109_ _7334_/CLK _7109_/D _6389_/Y VGND VGND VPWR VPWR _7109_/Q sky130_fd_sc_hd__dfrtp_2
XFILLER_101_374 VGND VGND VPWR VPWR sky130_fd_sc_hd__decap_3
XFILLER_19_119 VGND VGND VPWR VPWR sky130_fd_sc_hd__decap_3
XFILLER_47_417 VGND VGND VPWR VPWR sky130_fd_sc_hd__fill_1
XFILLER_59_277 VGND VGND VPWR VPWR sky130_fd_sc_hd__decap_3
XFILLER_74_203 VGND VGND VPWR VPWR sky130_fd_sc_hd__decap_3
XFILLER_101_396 VGND VGND VPWR VPWR sky130_fd_sc_hd__decap_3
XFILLER_19_76 VGND VGND VPWR VPWR sky130_fd_sc_hd__decap_3
XFILLER_19_98 VGND VGND VPWR VPWR sky130_fd_sc_hd__decap_3
XFILLER_74_236 VGND VGND VPWR VPWR sky130_fd_sc_hd__decap_3
XTAP_TAPCELL_ROW_58_946 VGND VPWR sky130_fd_sc_hd__tapvpwrvgnd_1
XFILLER_43_601 VGND VGND VPWR VPWR sky130_fd_sc_hd__decap_3
XFILLER_55_461 VGND VGND VPWR VPWR sky130_fd_sc_hd__decap_3
XTAP_TAPCELL_ROW_2_273 VGND VPWR sky130_fd_sc_hd__tapvpwrvgnd_1
XFILLER_27_174 VGND VGND VPWR VPWR sky130_fd_sc_hd__decap_3
XFILLER_43_645 VGND VGND VPWR VPWR sky130_fd_sc_hd__fill_1
XFILLER_42_144 VGND VGND VPWR VPWR sky130_fd_sc_hd__decap_3
XFILLER_70_442 VGND VGND VPWR VPWR sky130_fd_sc_hd__decap_3
XTAP_TAPCELL_ROW_83_1248 VGND VPWR sky130_fd_sc_hd__tapvpwrvgnd_1
XFILLER_42_188 VGND VGND VPWR VPWR sky130_fd_sc_hd__decap_3
XFILLER_70_486 VGND VGND VPWR VPWR sky130_fd_sc_hd__decap_3
XFILLER_23_380 VGND VGND VPWR VPWR sky130_fd_sc_hd__fill_2
XFILLER_30_339 VGND VGND VPWR VPWR sky130_fd_sc_hd__fill_2
XFILLER_51_63 VGND VGND VPWR VPWR sky130_fd_sc_hd__decap_3
XFILLER_7_502 VGND VGND VPWR VPWR sky130_fd_sc_hd__fill_2
XFILLER_7_513 VGND VGND VPWR VPWR sky130_fd_sc_hd__decap_3
XFILLER_11_597 VGND VGND VPWR VPWR sky130_fd_sc_hd__fill_2
XFILLER_109_452 VGND VGND VPWR VPWR sky130_fd_sc_hd__decap_3
XFILLER_2_240 VGND VGND VPWR VPWR sky130_fd_sc_hd__fill_1
XTAP_TAPCELL_ROW_94_1377 VGND VPWR sky130_fd_sc_hd__tapvpwrvgnd_1
XFILLER_105_691 VGND VGND VPWR VPWR sky130_fd_sc_hd__fill_1
XFILLER_111_105 VGND VGND VPWR VPWR sky130_fd_sc_hd__decap_3
XFILLER_111_116 VGND VGND VPWR VPWR sky130_fd_sc_hd__decap_3
XFILLER_112_628 VGND VGND VPWR VPWR sky130_fd_sc_hd__decap_3
XFILLER_97_317 VGND VGND VPWR VPWR sky130_fd_sc_hd__fill_1
XFILLER_111_149 VGND VGND VPWR VPWR sky130_fd_sc_hd__decap_3
XFILLER_2_295 VGND VGND VPWR VPWR sky130_fd_sc_hd__fill_2
XFILLER_93_501 VGND VGND VPWR VPWR sky130_fd_sc_hd__decap_3
XFILLER_18_6 VGND VGND VPWR VPWR sky130_fd_sc_hd__decap_3
XFILLER_65_225 VGND VGND VPWR VPWR sky130_fd_sc_hd__fill_1
XFILLER_76_71 VGND VGND VPWR VPWR sky130_fd_sc_hd__decap_3
XFILLER_93_556 VGND VGND VPWR VPWR sky130_fd_sc_hd__decap_3
XFILLER_18_130 VGND VGND VPWR VPWR sky130_fd_sc_hd__fill_2
XFILLER_18_152 VGND VGND VPWR VPWR sky130_fd_sc_hd__decap_3
XFILLER_34_645 VGND VGND VPWR VPWR sky130_fd_sc_hd__fill_2
X_4810_ _4813_/A _4810_/B _4829_/B VGND VGND VPWR VPWR _4810_/X sky130_fd_sc_hd__or3_2
XFILLER_33_155 VGND VGND VPWR VPWR sky130_fd_sc_hd__decap_3
XFILLER_14_380 VGND VGND VPWR VPWR sky130_fd_sc_hd__decap_3
XFILLER_33_199 VGND VGND VPWR VPWR sky130_fd_sc_hd__decap_3
X_4741_ _4761_/B _4761_/C _4762_/B VGND VGND VPWR VPWR _4741_/X sky130_fd_sc_hd__a21o_2
XTAP_TAPCELL_ROW_103_1484 VGND VPWR sky130_fd_sc_hd__tapvpwrvgnd_1
X_4672_ _6991_/Q _5633_/B VGND VGND VPWR VPWR _4673_/B sky130_fd_sc_hd__nor2_2
X_6411_ _6535_/A VGND VGND VPWR VPWR _6411_/Y sky130_fd_sc_hd__inv_2
X_7391_ _7392_/CLK _7391_/D _6671_/Y VGND VGND VPWR VPWR _7391_/Q sky130_fd_sc_hd__dfrtp_2
X_6342_ _6347_/A VGND VGND VPWR VPWR _6342_/Y sky130_fd_sc_hd__inv_2
X_3554_ _7317_/Q _3989_/S _4338_/B1 _7349_/Q VGND VGND VPWR VPWR _3556_/B sky130_fd_sc_hd__a22o_2
XFILLER_103_617 VGND VGND VPWR VPWR sky130_fd_sc_hd__decap_3
X_6273_ _6275_/A VGND VGND VPWR VPWR _6273_/Y sky130_fd_sc_hd__inv_2
X_3485_ _3502_/A _3502_/B _3485_/C VGND VGND VPWR VPWR _5144_/A sky130_fd_sc_hd__or3_4
XFILLER_88_317 VGND VGND VPWR VPWR sky130_fd_sc_hd__decap_3
XFILLER_102_138 VGND VGND VPWR VPWR sky130_fd_sc_hd__fill_2
XFILLER_69_531 VGND VGND VPWR VPWR sky130_fd_sc_hd__decap_3
XFILLER_111_650 VGND VGND VPWR VPWR sky130_fd_sc_hd__decap_3
XFILLER_29_417 VGND VGND VPWR VPWR sky130_fd_sc_hd__decap_3
X_5155_ _4467_/B _3923_/X _5151_/X _5154_/Y VGND VGND VPWR VPWR _5155_/X sky130_fd_sc_hd__a31o_2
XFILLER_110_171 VGND VGND VPWR VPWR sky130_fd_sc_hd__decap_3
XFILLER_56_236 VGND VGND VPWR VPWR sky130_fd_sc_hd__decap_3
X_5086_ _5086_/A _5101_/B _5100_/B VGND VGND VPWR VPWR _5086_/X sky130_fd_sc_hd__and3_2
X_4106_ _7141_/Q _4434_/B1 _4103_/X _4105_/X VGND VGND VPWR VPWR _4106_/X sky130_fd_sc_hd__a211o_2
XFILLER_112_14 VGND VGND VPWR VPWR sky130_fd_sc_hd__decap_3
XFILLER_25_601 VGND VGND VPWR VPWR sky130_fd_sc_hd__decap_3
XFILLER_84_589 VGND VGND VPWR VPWR sky130_fd_sc_hd__fill_1
X_4037_ _4394_/A _4394_/B _4036_/X VGND VGND VPWR VPWR _4458_/A sky130_fd_sc_hd__or3b_2
XTAP_TAPCELL_ROW_55_916 VGND VPWR sky130_fd_sc_hd__tapvpwrvgnd_1
XFILLER_112_47 VGND VGND VPWR VPWR sky130_fd_sc_hd__decap_3
XFILLER_24_100 VGND VGND VPWR VPWR sky130_fd_sc_hd__decap_3
XFILLER_71_217 VGND VGND VPWR VPWR sky130_fd_sc_hd__decap_3
XFILLER_71_239 VGND VGND VPWR VPWR sky130_fd_sc_hd__decap_3
XTAP_TAPCELL_ROW_69_1081 VGND VPWR sky130_fd_sc_hd__tapvpwrvgnd_1
XFILLER_52_442 VGND VGND VPWR VPWR sky130_fd_sc_hd__decap_3
XFILLER_72_18 VGND VGND VPWR VPWR sky130_fd_sc_hd__decap_3
XFILLER_52_475 VGND VGND VPWR VPWR sky130_fd_sc_hd__fill_1
XTAP_TAPCELL_ROW_35_673 VGND VPWR sky130_fd_sc_hd__tapvpwrvgnd_1
XFILLER_12_328 VGND VGND VPWR VPWR sky130_fd_sc_hd__decap_3
XFILLER_24_188 VGND VGND VPWR VPWR sky130_fd_sc_hd__decap_3
X_4939_ _4764_/B _4379_/B _4938_/Y _4937_/A _4852_/A VGND VGND VPWR VPWR _4939_/X
+ sky130_fd_sc_hd__o32a_2
X_6609_ _6643_/A VGND VGND VPWR VPWR _6609_/Y sky130_fd_sc_hd__inv_2
XFILLER_21_33 VGND VGND VPWR VPWR sky130_fd_sc_hd__decap_3
XFILLER_106_466 VGND VGND VPWR VPWR sky130_fd_sc_hd__decap_3
XFILLER_21_99 VGND VGND VPWR VPWR sky130_fd_sc_hd__decap_3
XFILLER_97_15 VGND VGND VPWR VPWR sky130_fd_sc_hd__decap_3
XFILLER_106_477 VGND VGND VPWR VPWR sky130_fd_sc_hd__fill_2
XFILLER_106_499 VGND VGND VPWR VPWR sky130_fd_sc_hd__decap_3
XTAP_TAPCELL_ROW_7_332 VGND VPWR sky130_fd_sc_hd__tapvpwrvgnd_1
XFILLER_102_672 VGND VGND VPWR VPWR sky130_fd_sc_hd__decap_3
XFILLER_47_225 VGND VGND VPWR VPWR sky130_fd_sc_hd__decap_3
XFILLER_75_523 VGND VGND VPWR VPWR sky130_fd_sc_hd__fill_1
XFILLER_28_450 VGND VGND VPWR VPWR sky130_fd_sc_hd__decap_3
XFILLER_75_578 VGND VGND VPWR VPWR sky130_fd_sc_hd__decap_3
XFILLER_15_100 VGND VGND VPWR VPWR sky130_fd_sc_hd__decap_3
XFILLER_16_634 VGND VGND VPWR VPWR sky130_fd_sc_hd__fill_1
XFILLER_46_85 VGND VGND VPWR VPWR sky130_fd_sc_hd__decap_3
XFILLER_62_217 VGND VGND VPWR VPWR sky130_fd_sc_hd__decap_3
XFILLER_90_548 VGND VGND VPWR VPWR sky130_fd_sc_hd__decap_3
XFILLER_16_645 VGND VGND VPWR VPWR sky130_fd_sc_hd__fill_1
XFILLER_102_91 VGND VGND VPWR VPWR sky130_fd_sc_hd__decap_3
XFILLER_15_177 VGND VGND VPWR VPWR sky130_fd_sc_hd__decap_3
XFILLER_16_678 VGND VGND VPWR VPWR sky130_fd_sc_hd__decap_3
XFILLER_30_103 VGND VGND VPWR VPWR sky130_fd_sc_hd__fill_1
XFILLER_43_464 VGND VGND VPWR VPWR sky130_fd_sc_hd__decap_3
XFILLER_30_114 VGND VGND VPWR VPWR sky130_fd_sc_hd__decap_3
XFILLER_31_637 VGND VGND VPWR VPWR sky130_fd_sc_hd__decap_3
XFILLER_43_497 VGND VGND VPWR VPWR sky130_fd_sc_hd__decap_3
XFILLER_62_62 VGND VGND VPWR VPWR sky130_fd_sc_hd__decap_3
XFILLER_70_283 VGND VGND VPWR VPWR sky130_fd_sc_hd__fill_2
XFILLER_87_9 VGND VGND VPWR VPWR sky130_fd_sc_hd__decap_3
XFILLER_11_372 VGND VGND VPWR VPWR sky130_fd_sc_hd__decap_3
XFILLER_7_24 VGND VGND VPWR VPWR sky130_fd_sc_hd__decap_3
XFILLER_7_332 VGND VGND VPWR VPWR sky130_fd_sc_hd__decap_3
XTAP_TAPCELL_ROW_96_1406 VGND VPWR sky130_fd_sc_hd__tapvpwrvgnd_1
XFILLER_7_343 VGND VGND VPWR VPWR sky130_fd_sc_hd__decap_3
XFILLER_7_57 VGND VGND VPWR VPWR sky130_fd_sc_hd__decap_3
XFILLER_109_293 VGND VGND VPWR VPWR sky130_fd_sc_hd__fill_1
XFILLER_7_376 VGND VGND VPWR VPWR sky130_fd_sc_hd__decap_3
XFILLER_98_615 VGND VGND VPWR VPWR sky130_fd_sc_hd__decap_3
XFILLER_97_103 VGND VGND VPWR VPWR sky130_fd_sc_hd__decap_3
XFILLER_98_648 VGND VGND VPWR VPWR sky130_fd_sc_hd__decap_3
XFILLER_112_436 VGND VGND VPWR VPWR sky130_fd_sc_hd__fill_2
XFILLER_3_593 VGND VGND VPWR VPWR sky130_fd_sc_hd__decap_3
XFILLER_97_136 VGND VGND VPWR VPWR sky130_fd_sc_hd__decap_3
XFILLER_66_512 VGND VGND VPWR VPWR sky130_fd_sc_hd__decap_3
XFILLER_78_350 VGND VGND VPWR VPWR sky130_fd_sc_hd__decap_3
XFILLER_16_3 VGND VGND VPWR VPWR sky130_fd_sc_hd__decap_3
XFILLER_38_247 VGND VGND VPWR VPWR sky130_fd_sc_hd__decap_3
XFILLER_66_556 VGND VGND VPWR VPWR sky130_fd_sc_hd__fill_1
XFILLER_66_589 VGND VGND VPWR VPWR sky130_fd_sc_hd__decap_3
XFILLER_93_353 VGND VGND VPWR VPWR sky130_fd_sc_hd__decap_3
X_6960_ _6965_/CLK _6960_/D VGND VGND VPWR VPWR _6960_/Q sky130_fd_sc_hd__dfxtp_2
XFILLER_19_461 VGND VGND VPWR VPWR sky130_fd_sc_hd__decap_3
XFILLER_53_228 VGND VGND VPWR VPWR sky130_fd_sc_hd__decap_3
XTAP_TAPCELL_ROW_105_1513 VGND VPWR sky130_fd_sc_hd__tapvpwrvgnd_1
XFILLER_34_431 VGND VGND VPWR VPWR sky130_fd_sc_hd__fill_2
X_6891_ _7005_/CLK _6891_/D VGND VGND VPWR VPWR _6891_/Q sky130_fd_sc_hd__dfxtp_2
XFILLER_61_272 VGND VGND VPWR VPWR sky130_fd_sc_hd__decap_3
XTAP_TAPCELL_ROW_32_632 VGND VPWR sky130_fd_sc_hd__tapvpwrvgnd_1
XFILLER_21_169 VGND VGND VPWR VPWR sky130_fd_sc_hd__fill_1
X_4724_ _4720_/A _4655_/X _4658_/B VGND VGND VPWR VPWR _4724_/X sky130_fd_sc_hd__o21a_2
XTAP_TAPCELL_ROW_60_974 VGND VPWR sky130_fd_sc_hd__tapvpwrvgnd_1
X_4655_ _4745_/A _4765_/B _4611_/Y _4762_/A _4744_/B VGND VGND VPWR VPWR _4655_/X
+ sky130_fd_sc_hd__a221o_2
X_7374_ _7374_/CLK _7374_/D _6654_/Y VGND VGND VPWR VPWR _7374_/Q sky130_fd_sc_hd__dfrtp_2
Xhold800 _6723_/Q VGND VGND VPWR VPWR _6723_/D sky130_fd_sc_hd__dlygate4sd3_1
Xhold811 _6899_/Q VGND VGND VPWR VPWR _6899_/D sky130_fd_sc_hd__dlygate4sd3_1
X_3606_ _4614_/B _3603_/B _5146_/B1 VGND VGND VPWR VPWR _3606_/X sky130_fd_sc_hd__o21a_2
XTAP_TAPCELL_ROW_116_1642 VGND VPWR sky130_fd_sc_hd__tapvpwrvgnd_1
XFILLER_107_14 VGND VGND VPWR VPWR sky130_fd_sc_hd__decap_3
XFILLER_1_508 VGND VGND VPWR VPWR sky130_fd_sc_hd__decap_3
XFILLER_89_604 VGND VGND VPWR VPWR sky130_fd_sc_hd__decap_3
Xhold822 _6906_/Q VGND VGND VPWR VPWR _6906_/D sky130_fd_sc_hd__dlygate4sd3_1
Xhold833 _6939_/Q VGND VGND VPWR VPWR _6939_/D sky130_fd_sc_hd__dlygate4sd3_1
Xhold844 _7076_/Q VGND VGND VPWR VPWR _7076_/D sky130_fd_sc_hd__dlygate4sd3_1
Xhold855 _7055_/Q VGND VGND VPWR VPWR _7055_/D sky130_fd_sc_hd__dlygate4sd3_1
Xmax_cap563 _4273_/Y VGND VGND VPWR VPWR _4994_/A2 sky130_fd_sc_hd__clkdlybuf4s25_1
X_6325_ _6674_/A VGND VGND VPWR VPWR _6325_/Y sky130_fd_sc_hd__inv_2
X_3537_ _3427_/B _3618_/C _5057_/A _3527_/A _3536_/Y VGND VGND VPWR VPWR _3537_/X
+ sky130_fd_sc_hd__o221a_2
XTAP_TAPCELL_ROW_116_1653 VGND VPWR sky130_fd_sc_hd__tapvpwrvgnd_1
XFILLER_103_425 VGND VGND VPWR VPWR sky130_fd_sc_hd__decap_3
XFILLER_107_47 VGND VGND VPWR VPWR sky130_fd_sc_hd__decap_3
XFILLER_115_252 VGND VGND VPWR VPWR sky130_fd_sc_hd__decap_3
XFILLER_88_114 VGND VGND VPWR VPWR sky130_fd_sc_hd__decap_3
XFILLER_89_626 VGND VGND VPWR VPWR sky130_fd_sc_hd__decap_3
Xhold866 _7106_/Q VGND VGND VPWR VPWR _7106_/D sky130_fd_sc_hd__dlygate4sd3_1
Xhold877 _7111_/Q VGND VGND VPWR VPWR _7111_/D sky130_fd_sc_hd__dlygate4sd3_1
Xhold888 _7072_/Q VGND VGND VPWR VPWR _7072_/D sky130_fd_sc_hd__dlygate4sd3_1
Xmax_cap574 _6523_/A VGND VGND VPWR VPWR _6275_/A sky130_fd_sc_hd__clkbuf_2
XFILLER_103_447 VGND VGND VPWR VPWR sky130_fd_sc_hd__fill_1
XFILLER_107_69 VGND VGND VPWR VPWR sky130_fd_sc_hd__decap_3
XFILLER_115_296 VGND VGND VPWR VPWR sky130_fd_sc_hd__fill_2
XFILLER_67_18 VGND VGND VPWR VPWR sky130_fd_sc_hd__decap_3
XFILLER_88_158 VGND VGND VPWR VPWR sky130_fd_sc_hd__fill_2
XFILLER_89_659 VGND VGND VPWR VPWR sky130_fd_sc_hd__decap_3
Xhold899 _7097_/Q VGND VGND VPWR VPWR _7097_/D sky130_fd_sc_hd__dlygate4sd3_1
X_3468_ _7281_/Q _5157_/S _4351_/A2 _7089_/Q _3467_/X VGND VGND VPWR VPWR _3468_/X
+ sky130_fd_sc_hd__a221o_2
X_5207_ _5207_/A _5225_/B VGND VGND VPWR VPWR _7225_/D sky130_fd_sc_hd__and2_2
X_3399_ _3977_/S _3399_/B VGND VGND VPWR VPWR _3449_/B sky130_fd_sc_hd__nor2_4
XTAP_TAPCELL_ROW_4_302 VGND VPWR sky130_fd_sc_hd__tapvpwrvgnd_1
XFILLER_29_225 VGND VGND VPWR VPWR sky130_fd_sc_hd__decap_3
XFILLER_84_331 VGND VGND VPWR VPWR sky130_fd_sc_hd__fill_1
X_5138_ _3665_/B _3914_/X _5151_/A VGND VGND VPWR VPWR _5138_/X sky130_fd_sc_hd__mux2_2
XFILLER_57_567 VGND VGND VPWR VPWR sky130_fd_sc_hd__decap_3
XFILLER_84_353 VGND VGND VPWR VPWR sky130_fd_sc_hd__decap_3
XFILLER_44_228 VGND VGND VPWR VPWR sky130_fd_sc_hd__decap_3
XFILLER_72_526 VGND VGND VPWR VPWR sky130_fd_sc_hd__decap_3
X_5069_ _6987_/Q _5069_/B VGND VGND VPWR VPWR _5069_/X sky130_fd_sc_hd__or2_2
XFILLER_16_44 VGND VGND VPWR VPWR sky130_fd_sc_hd__decap_3
XFILLER_13_604 VGND VGND VPWR VPWR sky130_fd_sc_hd__decap_3
XFILLER_16_77 VGND VGND VPWR VPWR sky130_fd_sc_hd__decap_3
XFILLER_25_464 VGND VGND VPWR VPWR sky130_fd_sc_hd__decap_3
XTAP_TAPCELL_ROW_80_1207 VGND VPWR sky130_fd_sc_hd__tapvpwrvgnd_1
XFILLER_13_659 VGND VGND VPWR VPWR sky130_fd_sc_hd__decap_3
XFILLER_52_272 VGND VGND VPWR VPWR sky130_fd_sc_hd__decap_3
XFILLER_12_147 VGND VGND VPWR VPWR sky130_fd_sc_hd__decap_3
XFILLER_8_118 VGND VGND VPWR VPWR sky130_fd_sc_hd__decap_3
XFILLER_4_313 VGND VGND VPWR VPWR sky130_fd_sc_hd__decap_3
XPHY_EDGE_ROW_112_Left_229 VGND VGND VPWR VPWR sky130_fd_sc_hd__decap_3
XFILLER_106_274 VGND VGND VPWR VPWR sky130_fd_sc_hd__decap_3
XTAP_TAPCELL_ROW_91_1347 VGND VPWR sky130_fd_sc_hd__tapvpwrvgnd_1
XFILLER_0_574 VGND VGND VPWR VPWR sky130_fd_sc_hd__decap_3
XFILLER_79_169 VGND VGND VPWR VPWR sky130_fd_sc_hd__decap_3
XFILLER_95_629 VGND VGND VPWR VPWR sky130_fd_sc_hd__decap_3
XFILLER_57_40 VGND VGND VPWR VPWR sky130_fd_sc_hd__decap_3
XFILLER_88_681 VGND VGND VPWR VPWR sky130_fd_sc_hd__decap_3
XFILLER_75_364 VGND VGND VPWR VPWR sky130_fd_sc_hd__decap_3
XFILLER_35_217 VGND VGND VPWR VPWR sky130_fd_sc_hd__decap_3
XFILLER_35_228 VGND VGND VPWR VPWR sky130_fd_sc_hd__decap_3
XFILLER_48_589 VGND VGND VPWR VPWR sky130_fd_sc_hd__fill_1
XFILLER_75_386 VGND VGND VPWR VPWR sky130_fd_sc_hd__decap_3
XFILLER_90_301 VGND VGND VPWR VPWR sky130_fd_sc_hd__decap_3
XFILLER_113_90 VGND VGND VPWR VPWR sky130_fd_sc_hd__decap_3
XFILLER_28_280 VGND VGND VPWR VPWR sky130_fd_sc_hd__decap_3
XFILLER_71_570 VGND VGND VPWR VPWR sky130_fd_sc_hd__decap_3
XFILLER_73_72 VGND VGND VPWR VPWR sky130_fd_sc_hd__decap_3
XFILLER_16_486 VGND VGND VPWR VPWR sky130_fd_sc_hd__fill_1
XFILLER_31_423 VGND VGND VPWR VPWR sky130_fd_sc_hd__decap_3
XFILLER_71_592 VGND VGND VPWR VPWR sky130_fd_sc_hd__decap_3
XTAP_TAPCELL_ROW_100_1454 VGND VPWR sky130_fd_sc_hd__tapvpwrvgnd_1
XFILLER_11_191 VGND VGND VPWR VPWR sky130_fd_sc_hd__decap_3
XFILLER_7_140 VGND VGND VPWR VPWR sky130_fd_sc_hd__decap_3
XFILLER_8_674 VGND VGND VPWR VPWR sky130_fd_sc_hd__decap_3
X_4440_ _4440_/A _4650_/B VGND VGND VPWR VPWR _4441_/B sky130_fd_sc_hd__nand2_2
XFILLER_112_200 VGND VGND VPWR VPWR sky130_fd_sc_hd__decap_3
X_4371_ _4371_/A _4371_/B VGND VGND VPWR VPWR _4371_/Y sky130_fd_sc_hd__nand2_2
XFILLER_98_412 VGND VGND VPWR VPWR sky130_fd_sc_hd__decap_3
XFILLER_112_233 VGND VGND VPWR VPWR sky130_fd_sc_hd__decap_3
XFILLER_3_390 VGND VGND VPWR VPWR sky130_fd_sc_hd__fill_2
X_7090_ clkload4/A _7090_/D _6370_/Y VGND VGND VPWR VPWR _7090_/Q sky130_fd_sc_hd__dfrtp_2
XFILLER_98_91 VGND VGND VPWR VPWR sky130_fd_sc_hd__decap_3
XFILLER_98_456 VGND VGND VPWR VPWR sky130_fd_sc_hd__decap_3
XFILLER_58_309 VGND VGND VPWR VPWR sky130_fd_sc_hd__decap_3
XFILLER_85_106 VGND VGND VPWR VPWR sky130_fd_sc_hd__decap_3
XFILLER_86_618 VGND VGND VPWR VPWR sky130_fd_sc_hd__decap_3
XFILLER_98_467 VGND VGND VPWR VPWR sky130_fd_sc_hd__decap_3
XFILLER_112_288 VGND VGND VPWR VPWR sky130_fd_sc_hd__decap_3
XFILLER_39_512 VGND VGND VPWR VPWR sky130_fd_sc_hd__fill_2
XFILLER_39_534 VGND VGND VPWR VPWR sky130_fd_sc_hd__decap_3
XFILLER_66_320 VGND VGND VPWR VPWR sky130_fd_sc_hd__decap_3
XTAP_TAPCELL_ROW_111_1583 VGND VPWR sky130_fd_sc_hd__tapvpwrvgnd_1
XFILLER_66_353 VGND VGND VPWR VPWR sky130_fd_sc_hd__decap_3
XFILLER_94_651 VGND VGND VPWR VPWR sky130_fd_sc_hd__decap_3
XFILLER_26_206 VGND VGND VPWR VPWR sky130_fd_sc_hd__decap_3
XFILLER_54_526 VGND VGND VPWR VPWR sky130_fd_sc_hd__fill_2
XFILLER_66_375 VGND VGND VPWR VPWR sky130_fd_sc_hd__decap_3
XFILLER_81_323 VGND VGND VPWR VPWR sky130_fd_sc_hd__decap_3
XFILLER_94_684 VGND VGND VPWR VPWR sky130_fd_sc_hd__decap_3
XFILLER_81_356 VGND VGND VPWR VPWR sky130_fd_sc_hd__decap_3
X_6943_ _7005_/CLK _6943_/D VGND VGND VPWR VPWR _6943_/Q sky130_fd_sc_hd__dfxtp_2
XFILLER_22_401 VGND VGND VPWR VPWR sky130_fd_sc_hd__decap_3
XFILLER_34_261 VGND VGND VPWR VPWR sky130_fd_sc_hd__fill_1
X_6874_ _7384_/CLK _6874_/D VGND VGND VPWR VPWR _6874_/Q sky130_fd_sc_hd__dfxtp_2
XTAP_TAPCELL_ROW_66_1040 VGND VPWR sky130_fd_sc_hd__tapvpwrvgnd_1
XFILLER_34_283 VGND VGND VPWR VPWR sky130_fd_sc_hd__decap_3
XFILLER_62_592 VGND VGND VPWR VPWR sky130_fd_sc_hd__decap_3
XTAP_TAPCELL_ROW_45_790 VGND VPWR sky130_fd_sc_hd__tapvpwrvgnd_1
X_4707_ _6998_/Q _6999_/Q _7000_/Q _4912_/A VGND VGND VPWR VPWR _4825_/B sky130_fd_sc_hd__and4_2
X_4638_ _4950_/A _4950_/B VGND VGND VPWR VPWR _4948_/B sky130_fd_sc_hd__and2_2
Xhold630 _6893_/Q VGND VGND VPWR VPWR _6893_/D sky130_fd_sc_hd__dlygate4sd3_1
XFILLER_116_561 VGND VGND VPWR VPWR sky130_fd_sc_hd__decap_3
XFILLER_116_583 VGND VGND VPWR VPWR sky130_fd_sc_hd__decap_3
X_7357_ _7360_/CLK _7357_/D _6637_/Y VGND VGND VPWR VPWR _7357_/Q sky130_fd_sc_hd__dfrtp_2
Xhold641 _6854_/Q VGND VGND VPWR VPWR _6854_/D sky130_fd_sc_hd__dlygate4sd3_1
Xhold652 _6913_/Q VGND VGND VPWR VPWR _6913_/D sky130_fd_sc_hd__dlygate4sd3_1
Xhold663 _6898_/Q VGND VGND VPWR VPWR _6898_/D sky130_fd_sc_hd__dlygate4sd3_1
X_4569_ _4569_/A _4577_/B VGND VGND VPWR VPWR _7296_/D sky130_fd_sc_hd__and2_2
XTAP_TAPCELL_ROW_77_1180 VGND VPWR sky130_fd_sc_hd__tapvpwrvgnd_1
XFILLER_103_233 VGND VGND VPWR VPWR sky130_fd_sc_hd__decap_3
XFILLER_89_445 VGND VGND VPWR VPWR sky130_fd_sc_hd__decap_3
X_7288_ clkload5/A _7288_/D _6568_/Y VGND VGND VPWR VPWR _7288_/Q sky130_fd_sc_hd__dfrtp_2
Xhold674 _6878_/Q VGND VGND VPWR VPWR _6878_/D sky130_fd_sc_hd__dlygate4sd3_1
Xhold685 _6777_/Q VGND VGND VPWR VPWR _6777_/D sky130_fd_sc_hd__dlygate4sd3_1
Xhold696 _6888_/Q VGND VGND VPWR VPWR _6888_/D sky130_fd_sc_hd__dlygate4sd3_1
X_6308_ _6672_/A VGND VGND VPWR VPWR _6308_/Y sky130_fd_sc_hd__inv_2
XFILLER_103_244 VGND VGND VPWR VPWR sky130_fd_sc_hd__decap_3
XFILLER_103_266 VGND VGND VPWR VPWR sky130_fd_sc_hd__decap_3
XFILLER_103_299 VGND VGND VPWR VPWR sky130_fd_sc_hd__decap_3
XFILLER_57_331 VGND VGND VPWR VPWR sky130_fd_sc_hd__decap_3
XFILLER_85_662 VGND VGND VPWR VPWR sky130_fd_sc_hd__decap_3
XFILLER_17_228 VGND VGND VPWR VPWR sky130_fd_sc_hd__decap_3
XFILLER_27_21 VGND VGND VPWR VPWR sky130_fd_sc_hd__decap_3
XFILLER_27_54 VGND VGND VPWR VPWR sky130_fd_sc_hd__fill_2
XFILLER_57_364 VGND VGND VPWR VPWR sky130_fd_sc_hd__decap_3
XFILLER_72_312 VGND VGND VPWR VPWR sky130_fd_sc_hd__decap_3
XFILLER_84_150 VGND VGND VPWR VPWR sky130_fd_sc_hd__decap_3
XFILLER_85_673 VGND VGND VPWR VPWR sky130_fd_sc_hd__decap_3
XFILLER_27_87 VGND VGND VPWR VPWR sky130_fd_sc_hd__decap_3
XFILLER_72_345 VGND VGND VPWR VPWR sky130_fd_sc_hd__decap_3
XFILLER_13_401 VGND VGND VPWR VPWR sky130_fd_sc_hd__fill_1
XFILLER_32_209 VGND VGND VPWR VPWR sky130_fd_sc_hd__decap_3
XFILLER_40_220 VGND VGND VPWR VPWR sky130_fd_sc_hd__decap_3
XFILLER_53_592 VGND VGND VPWR VPWR sky130_fd_sc_hd__decap_3
XTAP_TAPCELL_ROW_15_429 VGND VPWR sky130_fd_sc_hd__tapvpwrvgnd_1
XFILLER_40_253 VGND VGND VPWR VPWR sky130_fd_sc_hd__decap_3
XFILLER_9_405 VGND VGND VPWR VPWR sky130_fd_sc_hd__decap_3
XFILLER_40_297 VGND VGND VPWR VPWR sky130_fd_sc_hd__fill_2
XFILLER_4_121 VGND VGND VPWR VPWR sky130_fd_sc_hd__decap_3
XFILLER_107_550 VGND VGND VPWR VPWR sky130_fd_sc_hd__fill_1
XFILLER_107_561 VGND VGND VPWR VPWR sky130_fd_sc_hd__fill_1
XFILLER_4_165 VGND VGND VPWR VPWR sky130_fd_sc_hd__fill_1
XFILLER_5_688 VGND VGND VPWR VPWR sky130_fd_sc_hd__decap_3
XFILLER_4_47 VGND VGND VPWR VPWR sky130_fd_sc_hd__decap_3
XFILLER_68_61 VGND VGND VPWR VPWR sky130_fd_sc_hd__decap_3
XFILLER_68_629 VGND VGND VPWR VPWR sky130_fd_sc_hd__decap_3
XFILLER_0_371 VGND VGND VPWR VPWR sky130_fd_sc_hd__decap_3
XFILLER_0_382 VGND VGND VPWR VPWR sky130_fd_sc_hd__decap_3
XFILLER_67_128 VGND VGND VPWR VPWR sky130_fd_sc_hd__decap_3
XFILLER_68_83 VGND VGND VPWR VPWR sky130_fd_sc_hd__fill_1
XFILLER_68_94 VGND VGND VPWR VPWR sky130_fd_sc_hd__decap_3
XFILLER_0_393 VGND VGND VPWR VPWR sky130_fd_sc_hd__decap_3
XFILLER_76_651 VGND VGND VPWR VPWR sky130_fd_sc_hd__decap_3
XFILLER_48_386 VGND VGND VPWR VPWR sky130_fd_sc_hd__decap_3
XFILLER_75_172 VGND VGND VPWR VPWR sky130_fd_sc_hd__decap_3
XFILLER_76_684 VGND VGND VPWR VPWR sky130_fd_sc_hd__decap_3
XFILLER_75_194 VGND VGND VPWR VPWR sky130_fd_sc_hd__decap_3
XFILLER_84_82 VGND VGND VPWR VPWR sky130_fd_sc_hd__fill_2
XFILLER_91_632 VGND VGND VPWR VPWR sky130_fd_sc_hd__decap_3
Xplace312 _4577_/B VGND VGND VPWR VPWR _4595_/B sky130_fd_sc_hd__buf_2
Xplace301 _3635_/B VGND VGND VPWR VPWR _5033_/B2 sky130_fd_sc_hd__buf_2
XFILLER_63_367 VGND VGND VPWR VPWR sky130_fd_sc_hd__decap_3
XFILLER_63_389 VGND VGND VPWR VPWR sky130_fd_sc_hd__decap_3
XFILLER_84_93 VGND VGND VPWR VPWR sky130_fd_sc_hd__decap_3
XFILLER_90_153 VGND VGND VPWR VPWR sky130_fd_sc_hd__decap_3
XFILLER_91_665 VGND VGND VPWR VPWR sky130_fd_sc_hd__decap_3
XFILLER_91_676 VGND VGND VPWR VPWR sky130_fd_sc_hd__decap_3
Xplace345 _4394_/B VGND VGND VPWR VPWR _4435_/B1 sky130_fd_sc_hd__buf_2
Xplace334 _3591_/A VGND VGND VPWR VPWR _4376_/A sky130_fd_sc_hd__buf_2
Xplace323 _3358_/X VGND VGND VPWR VPWR _4341_/A2 sky130_fd_sc_hd__buf_2
XFILLER_44_592 VGND VGND VPWR VPWR sky130_fd_sc_hd__fill_2
XFILLER_90_197 VGND VGND VPWR VPWR sky130_fd_sc_hd__decap_3
Xplace389 _5666_/A VGND VGND VPWR VPWR _4997_/A1 sky130_fd_sc_hd__buf_2
Xplace378 _3442_/A VGND VGND VPWR VPWR _5104_/A sky130_fd_sc_hd__buf_2
Xplace367 _4347_/C1 VGND VGND VPWR VPWR _4248_/A sky130_fd_sc_hd__buf_2
Xplace356 _4946_/S VGND VGND VPWR VPWR _4417_/A2 sky130_fd_sc_hd__buf_2
XFILLER_16_294 VGND VGND VPWR VPWR sky130_fd_sc_hd__fill_1
XFILLER_31_231 VGND VGND VPWR VPWR sky130_fd_sc_hd__decap_3
X_3871_ _6785_/Q _3907_/A2 _3917_/B1 _6873_/Q VGND VGND VPWR VPWR _3871_/X sky130_fd_sc_hd__a22o_2
XFILLER_83_3 VGND VGND VPWR VPWR sky130_fd_sc_hd__decap_3
X_6590_ _6651_/A VGND VGND VPWR VPWR _6590_/Y sky130_fd_sc_hd__inv_2
XTAP_TAPCELL_ROW_42_760 VGND VPWR sky130_fd_sc_hd__tapvpwrvgnd_1
X_7211_ _7363_/CLK _7211_/D _6491_/Y VGND VGND VPWR VPWR _7211_/Q sky130_fd_sc_hd__dfrtp_2
X_4423_ _7080_/Q _4432_/A2 _4432_/B1 _4422_/X VGND VGND VPWR VPWR _4649_/B sky130_fd_sc_hd__o211ai_2
XTAP_TAPCELL_ROW_113_1612 VGND VPWR sky130_fd_sc_hd__tapvpwrvgnd_1
X_7142_ _7334_/CLK _7142_/D _6422_/Y VGND VGND VPWR VPWR _7142_/Q sky130_fd_sc_hd__dfrtp_2
X_4354_ _7038_/Q _4510_/S _4354_/B1 _7385_/Q VGND VGND VPWR VPWR _4355_/B sky130_fd_sc_hd__a22o_2
XFILLER_98_231 VGND VGND VPWR VPWR sky130_fd_sc_hd__decap_3
XFILLER_113_553 VGND VGND VPWR VPWR sky130_fd_sc_hd__decap_3
XFILLER_113_564 VGND VGND VPWR VPWR sky130_fd_sc_hd__decap_3
XFILLER_58_106 VGND VGND VPWR VPWR sky130_fd_sc_hd__fill_2
XFILLER_59_629 VGND VGND VPWR VPWR sky130_fd_sc_hd__decap_3
XFILLER_86_404 VGND VGND VPWR VPWR sky130_fd_sc_hd__decap_3
X_7073_ _7265_/CLK _7073_/D _6353_/Y VGND VGND VPWR VPWR _7073_/Q sky130_fd_sc_hd__dfrtp_2
X_3305_ _6983_/Q VGND VGND VPWR VPWR _3340_/B sky130_fd_sc_hd__inv_2
XFILLER_98_253 VGND VGND VPWR VPWR sky130_fd_sc_hd__decap_3
XFILLER_100_203 VGND VGND VPWR VPWR sky130_fd_sc_hd__decap_3
XFILLER_113_597 VGND VGND VPWR VPWR sky130_fd_sc_hd__decap_3
X_4285_ _7035_/Q _4534_/S _4332_/B1 _7382_/Q VGND VGND VPWR VPWR _4286_/B sky130_fd_sc_hd__a22o_2
XFILLER_98_275 VGND VGND VPWR VPWR sky130_fd_sc_hd__decap_3
XFILLER_100_247 VGND VGND VPWR VPWR sky130_fd_sc_hd__decap_3
XFILLER_104_15 VGND VGND VPWR VPWR sky130_fd_sc_hd__decap_3
XFILLER_39_320 VGND VGND VPWR VPWR sky130_fd_sc_hd__fill_1
XFILLER_67_662 VGND VGND VPWR VPWR sky130_fd_sc_hd__decap_3
XFILLER_104_48 VGND VGND VPWR VPWR sky130_fd_sc_hd__decap_3
XFILLER_66_150 VGND VGND VPWR VPWR sky130_fd_sc_hd__decap_3
XFILLER_67_673 VGND VGND VPWR VPWR sky130_fd_sc_hd__decap_3
XFILLER_82_610 VGND VGND VPWR VPWR sky130_fd_sc_hd__decap_3
XFILLER_27_537 VGND VGND VPWR VPWR sky130_fd_sc_hd__decap_3
XFILLER_27_559 VGND VGND VPWR VPWR sky130_fd_sc_hd__fill_1
XFILLER_66_183 VGND VGND VPWR VPWR sky130_fd_sc_hd__fill_1
XFILLER_81_131 VGND VGND VPWR VPWR sky130_fd_sc_hd__decap_3
XFILLER_82_643 VGND VGND VPWR VPWR sky130_fd_sc_hd__fill_1
XFILLER_82_654 VGND VGND VPWR VPWR sky130_fd_sc_hd__decap_3
XFILLER_54_356 VGND VGND VPWR VPWR sky130_fd_sc_hd__decap_3
XFILLER_82_687 VGND VGND VPWR VPWR sky130_fd_sc_hd__decap_3
X_6926_ _6965_/CLK _6926_/D VGND VGND VPWR VPWR _6926_/Q sky130_fd_sc_hd__dfxtp_2
XFILLER_54_389 VGND VGND VPWR VPWR sky130_fd_sc_hd__decap_3
XFILLER_81_175 VGND VGND VPWR VPWR sky130_fd_sc_hd__decap_3
XFILLER_22_220 VGND VGND VPWR VPWR sky130_fd_sc_hd__decap_3
XFILLER_80_18 VGND VGND VPWR VPWR sky130_fd_sc_hd__decap_3
Xfanout24 _6600_/A VGND VGND VPWR VPWR _6570_/A sky130_fd_sc_hd__clkbuf_2
Xfanout35 fanout38/X VGND VGND VPWR VPWR _6640_/A sky130_fd_sc_hd__clkdlybuf4s25_1
Xfanout46 _6643_/A VGND VGND VPWR VPWR _6483_/A sky130_fd_sc_hd__buf_1
X_6857_ _6946_/CLK _6857_/D VGND VGND VPWR VPWR _6857_/Q sky130_fd_sc_hd__dfxtp_2
XFILLER_13_23 VGND VGND VPWR VPWR sky130_fd_sc_hd__decap_3
XFILLER_22_264 VGND VGND VPWR VPWR sky130_fd_sc_hd__decap_3
XFILLER_50_562 VGND VGND VPWR VPWR sky130_fd_sc_hd__decap_3
Xfanout57 _6285_/A VGND VGND VPWR VPWR _6686_/A sky130_fd_sc_hd__clkdlybuf4s25_1
Xfanout68 fanout72/X VGND VGND VPWR VPWR _6619_/A sky130_fd_sc_hd__clkdlybuf4s25_1
X_6788_ _7386_/CLK _6788_/D VGND VGND VPWR VPWR _6788_/Q sky130_fd_sc_hd__dfxtp_2
XFILLER_22_297 VGND VGND VPWR VPWR sky130_fd_sc_hd__decap_3
XFILLER_6_408 VGND VGND VPWR VPWR sky130_fd_sc_hd__decap_3
XFILLER_13_78 VGND VGND VPWR VPWR sky130_fd_sc_hd__fill_2
XTAP_TAPCELL_ROW_20_487 VGND VPWR sky130_fd_sc_hd__tapvpwrvgnd_1
XFILLER_104_520 VGND VGND VPWR VPWR sky130_fd_sc_hd__decap_3
XFILLER_116_391 VGND VGND VPWR VPWR sky130_fd_sc_hd__fill_1
XFILLER_1_102 VGND VGND VPWR VPWR sky130_fd_sc_hd__decap_3
XFILLER_1_113 VGND VGND VPWR VPWR sky130_fd_sc_hd__decap_3
XFILLER_2_636 VGND VGND VPWR VPWR sky130_fd_sc_hd__decap_3
XFILLER_89_220 VGND VGND VPWR VPWR sky130_fd_sc_hd__decap_3
XFILLER_89_231 VGND VGND VPWR VPWR sky130_fd_sc_hd__decap_3
XFILLER_1_146 VGND VGND VPWR VPWR sky130_fd_sc_hd__decap_3
XFILLER_2_669 VGND VGND VPWR VPWR sky130_fd_sc_hd__decap_3
XFILLER_89_297 VGND VGND VPWR VPWR sky130_fd_sc_hd__fill_1
XFILLER_38_42 VGND VGND VPWR VPWR sky130_fd_sc_hd__fill_2
XFILLER_58_640 VGND VGND VPWR VPWR sky130_fd_sc_hd__decap_3
XFILLER_58_651 VGND VGND VPWR VPWR sky130_fd_sc_hd__decap_3
XFILLER_92_407 VGND VGND VPWR VPWR sky130_fd_sc_hd__decap_3
XFILLER_57_150 VGND VGND VPWR VPWR sky130_fd_sc_hd__decap_3
Xhold1160 _7269_/Q VGND VGND VPWR VPWR _4879_/A0 sky130_fd_sc_hd__dlygate4sd3_1
XFILLER_45_323 VGND VGND VPWR VPWR sky130_fd_sc_hd__fill_2
XFILLER_45_334 VGND VGND VPWR VPWR sky130_fd_sc_hd__fill_2
XFILLER_57_172 VGND VGND VPWR VPWR sky130_fd_sc_hd__decap_3
XFILLER_73_632 VGND VGND VPWR VPWR sky130_fd_sc_hd__decap_3
Xhold1171 _7235_/Q VGND VGND VPWR VPWR _5186_/A sky130_fd_sc_hd__dlygate4sd3_1
Xhold1182 _7181_/Q VGND VGND VPWR VPWR _5298_/A0 sky130_fd_sc_hd__dlygate4sd3_1
Xhold1193 _7400_/Q VGND VGND VPWR VPWR _3705_/A0 sky130_fd_sc_hd__dlygate4sd3_1
XFILLER_73_665 VGND VGND VPWR VPWR sky130_fd_sc_hd__decap_3
XFILLER_73_676 VGND VGND VPWR VPWR sky130_fd_sc_hd__decap_3
XTAP_TAPCELL_ROW_86_1279 VGND VPWR sky130_fd_sc_hd__tapvpwrvgnd_1
XFILLER_54_74 VGND VGND VPWR VPWR sky130_fd_sc_hd__decap_3
XFILLER_72_186 VGND VGND VPWR VPWR sky130_fd_sc_hd__decap_3
XTAP_TAPCELL_ROW_28_587 VGND VPWR sky130_fd_sc_hd__tapvpwrvgnd_1
XFILLER_13_231 VGND VGND VPWR VPWR sky130_fd_sc_hd__fill_1
XFILLER_54_85 VGND VGND VPWR VPWR sky130_fd_sc_hd__decap_3
XFILLER_110_80 VGND VGND VPWR VPWR sky130_fd_sc_hd__decap_3
XFILLER_110_91 VGND VGND VPWR VPWR sky130_fd_sc_hd__decap_3
XFILLER_70_40 VGND VGND VPWR VPWR sky130_fd_sc_hd__decap_3
XFILLER_9_246 VGND VGND VPWR VPWR sky130_fd_sc_hd__decap_3
XFILLER_70_73 VGND VGND VPWR VPWR sky130_fd_sc_hd__decap_3
Xclkload16 _6975_/CLK VGND VGND VPWR VPWR clkload16/Y sky130_fd_sc_hd__clkinv_2
Xclkload27 _7402_/CLK VGND VGND VPWR VPWR clkload27/Y sky130_fd_sc_hd__bufinv_16
XFILLER_5_441 VGND VGND VPWR VPWR sky130_fd_sc_hd__decap_3
XFILLER_5_452 VGND VGND VPWR VPWR sky130_fd_sc_hd__decap_3
XFILLER_114_339 VGND VGND VPWR VPWR sky130_fd_sc_hd__decap_3
XFILLER_48_6 VGND VGND VPWR VPWR sky130_fd_sc_hd__decap_3
XFILLER_79_60 VGND VGND VPWR VPWR sky130_fd_sc_hd__decap_3
XFILLER_95_201 VGND VGND VPWR VPWR sky130_fd_sc_hd__fill_1
XFILLER_95_223 VGND VGND VPWR VPWR sky130_fd_sc_hd__fill_1
XFILLER_110_545 VGND VGND VPWR VPWR sky130_fd_sc_hd__decap_3
XFILLER_95_234 VGND VGND VPWR VPWR sky130_fd_sc_hd__decap_3
X_4070_ _7339_/Q _3945_/S _5229_/C _7147_/Q VGND VGND VPWR VPWR _4070_/X sky130_fd_sc_hd__a22o_2
XFILLER_110_578 VGND VGND VPWR VPWR sky130_fd_sc_hd__decap_3
XFILLER_110_589 VGND VGND VPWR VPWR sky130_fd_sc_hd__decap_3
XFILLER_36_301 VGND VGND VPWR VPWR sky130_fd_sc_hd__decap_3
XFILLER_48_150 VGND VGND VPWR VPWR sky130_fd_sc_hd__decap_3
XFILLER_49_662 VGND VGND VPWR VPWR sky130_fd_sc_hd__decap_3
XFILLER_49_673 VGND VGND VPWR VPWR sky130_fd_sc_hd__decap_3
XFILLER_64_610 VGND VGND VPWR VPWR sky130_fd_sc_hd__decap_3
XFILLER_95_267 VGND VGND VPWR VPWR sky130_fd_sc_hd__decap_3
XFILLER_95_92 VGND VGND VPWR VPWR sky130_fd_sc_hd__decap_3
XFILLER_36_312 VGND VGND VPWR VPWR sky130_fd_sc_hd__fill_2
XFILLER_36_323 VGND VGND VPWR VPWR sky130_fd_sc_hd__decap_3
XFILLER_48_172 VGND VGND VPWR VPWR sky130_fd_sc_hd__fill_2
XFILLER_48_183 VGND VGND VPWR VPWR sky130_fd_sc_hd__decap_3
XFILLER_64_643 VGND VGND VPWR VPWR sky130_fd_sc_hd__fill_1
XFILLER_64_654 VGND VGND VPWR VPWR sky130_fd_sc_hd__decap_3
XFILLER_24_518 VGND VGND VPWR VPWR sky130_fd_sc_hd__fill_1
XFILLER_63_131 VGND VGND VPWR VPWR sky130_fd_sc_hd__decap_3
XFILLER_63_164 VGND VGND VPWR VPWR sky130_fd_sc_hd__decap_3
XFILLER_64_687 VGND VGND VPWR VPWR sky130_fd_sc_hd__decap_3
XFILLER_17_570 VGND VGND VPWR VPWR sky130_fd_sc_hd__decap_3
XFILLER_51_337 VGND VGND VPWR VPWR sky130_fd_sc_hd__decap_3
X_4972_ _5661_/B VGND VGND VPWR VPWR _4973_/B sky130_fd_sc_hd__inv_2
XTAP_TAPCELL_ROW_63_1010 VGND VPWR sky130_fd_sc_hd__tapvpwrvgnd_1
X_6711_ _7403_/CLK _6711_/D VGND VGND VPWR VPWR _6711_/Q sky130_fd_sc_hd__dfxtp_2
X_3923_ _5660_/A _3922_/X _5104_/A VGND VGND VPWR VPWR _3923_/X sky130_fd_sc_hd__a21o_2
XFILLER_32_562 VGND VGND VPWR VPWR sky130_fd_sc_hd__fill_1
X_6642_ _6642_/A VGND VGND VPWR VPWR _6642_/Y sky130_fd_sc_hd__inv_2
X_3854_ _3725_/X _3851_/X _3853_/X _3735_/X VGND VGND VPWR VPWR _3854_/X sky130_fd_sc_hd__a22o_2
X_6573_ _6638_/A VGND VGND VPWR VPWR _6573_/Y sky130_fd_sc_hd__inv_2
X_3785_ _6837_/Q _3651_/Y _3893_/B1 _6832_/Q _3784_/X VGND VGND VPWR VPWR _3785_/X
+ sky130_fd_sc_hd__a221o_2
Xoutput510 _5649_/X VGND VGND VPWR VPWR instruction_out[26] sky130_fd_sc_hd__clkdlybuf4s25_1
Xoutput543 _7006_/Q VGND VGND VPWR VPWR pc_out[29] sky130_fd_sc_hd__clkdlybuf4s25_1
Xoutput532 _6996_/Q VGND VGND VPWR VPWR pc_out[19] sky130_fd_sc_hd__clkdlybuf4s25_1
Xoutput521 _5646_/Y VGND VGND VPWR VPWR instruction_out[9] sky130_fd_sc_hd__clkdlybuf4s25_1
X_4406_ _7402_/Q _4429_/B1 _4434_/B1 _7146_/Q _4405_/X VGND VGND VPWR VPWR _4406_/X
+ sky130_fd_sc_hd__a221o_2
XFILLER_5_90 VGND VGND VPWR VPWR sky130_fd_sc_hd__decap_3
X_7125_ clkload5/A _7125_/D _6405_/Y VGND VGND VPWR VPWR _7125_/Q sky130_fd_sc_hd__dfrtp_2
X_5386_ _5386_/A0 _4899_/X _5386_/S VGND VGND VPWR VPWR _7140_/D sky130_fd_sc_hd__mux2_2
XFILLER_113_383 VGND VGND VPWR VPWR sky130_fd_sc_hd__decap_3
XFILLER_115_14 VGND VGND VPWR VPWR sky130_fd_sc_hd__decap_3
XFILLER_86_212 VGND VGND VPWR VPWR sky130_fd_sc_hd__decap_3
X_4337_ _4394_/A _4337_/B _4336_/X VGND VGND VPWR VPWR _4365_/C sky130_fd_sc_hd__or3b_2
XFILLER_101_534 VGND VGND VPWR VPWR sky130_fd_sc_hd__decap_3
XFILLER_115_47 VGND VGND VPWR VPWR sky130_fd_sc_hd__decap_3
XFILLER_115_69 VGND VGND VPWR VPWR sky130_fd_sc_hd__decap_3
XFILLER_86_234 VGND VGND VPWR VPWR sky130_fd_sc_hd__fill_1
XFILLER_86_256 VGND VGND VPWR VPWR sky130_fd_sc_hd__decap_3
X_7056_ clkload5/A _7056_/D _6336_/Y VGND VGND VPWR VPWR _7056_/Q sky130_fd_sc_hd__dfstp_2
X_4268_ _7198_/Q _4268_/A2 _4354_/B1 _7390_/Q VGND VGND VPWR VPWR _4268_/X sky130_fd_sc_hd__a22o_2
XFILLER_75_29 VGND VGND VPWR VPWR sky130_fd_sc_hd__decap_3
XFILLER_86_289 VGND VGND VPWR VPWR sky130_fd_sc_hd__decap_3
XFILLER_39_172 VGND VGND VPWR VPWR sky130_fd_sc_hd__decap_3
XFILLER_39_194 VGND VGND VPWR VPWR sky130_fd_sc_hd__decap_3
XFILLER_55_632 VGND VGND VPWR VPWR sky130_fd_sc_hd__decap_3
X_4199_ _4380_/A _4380_/B VGND VGND VPWR VPWR _4381_/A sky130_fd_sc_hd__nand2_2
XFILLER_54_153 VGND VGND VPWR VPWR sky130_fd_sc_hd__decap_3
XFILLER_55_665 VGND VGND VPWR VPWR sky130_fd_sc_hd__decap_3
XFILLER_55_676 VGND VGND VPWR VPWR sky130_fd_sc_hd__decap_3
XFILLER_27_389 VGND VGND VPWR VPWR sky130_fd_sc_hd__decap_3
XFILLER_54_197 VGND VGND VPWR VPWR sky130_fd_sc_hd__decap_3
XFILLER_70_613 VGND VGND VPWR VPWR sky130_fd_sc_hd__decap_3
XFILLER_91_39 VGND VGND VPWR VPWR sky130_fd_sc_hd__decap_3
XFILLER_24_11 VGND VGND VPWR VPWR sky130_fd_sc_hd__decap_3
XFILLER_42_359 VGND VGND VPWR VPWR sky130_fd_sc_hd__decap_3
XFILLER_70_657 VGND VGND VPWR VPWR sky130_fd_sc_hd__decap_3
X_6909_ _6909_/CLK _6909_/D VGND VGND VPWR VPWR _6909_/Q sky130_fd_sc_hd__dfxtp_2
XTAP_TAPCELL_ROW_25_557 VGND VPWR sky130_fd_sc_hd__tapvpwrvgnd_1
XTAP_TAPCELL_ROW_25_546 VGND VPWR sky130_fd_sc_hd__tapvpwrvgnd_1
XTAP_TAPCELL_ROW_53_888 VGND VPWR sky130_fd_sc_hd__tapvpwrvgnd_1
XFILLER_10_212 VGND VGND VPWR VPWR sky130_fd_sc_hd__decap_3
XFILLER_24_88 VGND VGND VPWR VPWR sky130_fd_sc_hd__decap_3
XFILLER_108_100 VGND VGND VPWR VPWR sky130_fd_sc_hd__decap_3
XFILLER_109_612 VGND VGND VPWR VPWR sky130_fd_sc_hd__decap_3
XFILLER_109_623 VGND VGND VPWR VPWR sky130_fd_sc_hd__decap_3
XFILLER_10_256 VGND VGND VPWR VPWR sky130_fd_sc_hd__decap_3
XFILLER_108_133 VGND VGND VPWR VPWR sky130_fd_sc_hd__decap_3
XFILLER_109_656 VGND VGND VPWR VPWR sky130_fd_sc_hd__decap_3
XFILLER_40_21 VGND VGND VPWR VPWR sky130_fd_sc_hd__decap_3
XFILLER_108_144 VGND VGND VPWR VPWR sky130_fd_sc_hd__decap_3
XFILLER_2_433 VGND VGND VPWR VPWR sky130_fd_sc_hd__decap_3
XFILLER_2_466 VGND VGND VPWR VPWR sky130_fd_sc_hd__decap_3
XFILLER_104_361 VGND VGND VPWR VPWR sky130_fd_sc_hd__decap_3
XFILLER_2_477 VGND VGND VPWR VPWR sky130_fd_sc_hd__decap_3
XFILLER_2_488 VGND VGND VPWR VPWR sky130_fd_sc_hd__fill_1
XFILLER_77_245 VGND VGND VPWR VPWR sky130_fd_sc_hd__decap_3
XFILLER_1_26 VGND VGND VPWR VPWR sky130_fd_sc_hd__decap_3
XFILLER_77_278 VGND VGND VPWR VPWR sky130_fd_sc_hd__fill_2
XTAP_TAPCELL_ROW_88_1308 VGND VPWR sky130_fd_sc_hd__tapvpwrvgnd_1
XFILLER_46_632 VGND VGND VPWR VPWR sky130_fd_sc_hd__decap_3
XFILLER_65_40 VGND VGND VPWR VPWR sky130_fd_sc_hd__decap_3
XFILLER_46_654 VGND VGND VPWR VPWR sky130_fd_sc_hd__decap_3
XFILLER_61_602 VGND VGND VPWR VPWR sky130_fd_sc_hd__decap_3
XFILLER_65_84 VGND VGND VPWR VPWR sky130_fd_sc_hd__decap_3
XFILLER_73_462 VGND VGND VPWR VPWR sky130_fd_sc_hd__decap_3
XFILLER_33_326 VGND VGND VPWR VPWR sky130_fd_sc_hd__decap_3
XFILLER_45_175 VGND VGND VPWR VPWR sky130_fd_sc_hd__decap_3
XFILLER_46_687 VGND VGND VPWR VPWR sky130_fd_sc_hd__decap_3
XFILLER_61_635 VGND VGND VPWR VPWR sky130_fd_sc_hd__decap_3
XFILLER_73_495 VGND VGND VPWR VPWR sky130_fd_sc_hd__fill_2
XFILLER_61_668 VGND VGND VPWR VPWR sky130_fd_sc_hd__decap_3
XFILLER_61_679 VGND VGND VPWR VPWR sky130_fd_sc_hd__decap_3
XFILLER_14_584 VGND VGND VPWR VPWR sky130_fd_sc_hd__decap_3
XFILLER_41_381 VGND VGND VPWR VPWR sky130_fd_sc_hd__decap_3
XTAP_TAPCELL_ROW_99_1437 VGND VPWR sky130_fd_sc_hd__tapvpwrvgnd_1
X_3570_ _7157_/Q _3409_/X _4272_/B _3469_/B wire568/X VGND VGND VPWR VPWR _3570_/X
+ sky130_fd_sc_hd__a2111o_2
XFILLER_115_615 VGND VGND VPWR VPWR sky130_fd_sc_hd__fill_1
XFILLER_115_626 VGND VGND VPWR VPWR sky130_fd_sc_hd__decap_3
XFILLER_114_103 VGND VGND VPWR VPWR sky130_fd_sc_hd__decap_3
XFILLER_114_136 VGND VGND VPWR VPWR sky130_fd_sc_hd__decap_3
XFILLER_115_659 VGND VGND VPWR VPWR sky130_fd_sc_hd__decap_3
X_5240_ _4788_/A _4788_/B _5238_/X _5240_/B2 VGND VGND VPWR VPWR _7210_/D sky130_fd_sc_hd__a22o_2
XFILLER_102_309 VGND VGND VPWR VPWR sky130_fd_sc_hd__decap_3
XFILLER_114_147 VGND VGND VPWR VPWR sky130_fd_sc_hd__decap_3
X_5171_ _5171_/A _5182_/B VGND VGND VPWR VPWR _7242_/D sky130_fd_sc_hd__and2_2
XPHY_EDGE_ROW_18_Right_18 VGND VGND VPWR VPWR sky130_fd_sc_hd__decap_3
XFILLER_68_223 VGND VGND VPWR VPWR sky130_fd_sc_hd__decap_3
XFILLER_68_245 VGND VGND VPWR VPWR sky130_fd_sc_hd__decap_3
XFILLER_96_554 VGND VGND VPWR VPWR sky130_fd_sc_hd__fill_1
X_4122_ _7204_/Q _3962_/S _4505_/S _7049_/Q _4121_/X VGND VGND VPWR VPWR _4122_/X
+ sky130_fd_sc_hd__a221o_2
XFILLER_110_353 VGND VGND VPWR VPWR sky130_fd_sc_hd__decap_3
XFILLER_96_587 VGND VGND VPWR VPWR sky130_fd_sc_hd__fill_1
X_4053_ _4054_/A _4456_/A VGND VGND VPWR VPWR _4055_/A sky130_fd_sc_hd__nor2_2
XFILLER_49_492 VGND VGND VPWR VPWR sky130_fd_sc_hd__decap_3
XFILLER_36_131 VGND VGND VPWR VPWR sky130_fd_sc_hd__decap_3
XFILLER_37_676 VGND VGND VPWR VPWR sky130_fd_sc_hd__decap_3
XFILLER_83_259 VGND VGND VPWR VPWR sky130_fd_sc_hd__fill_1
XTAP_TAPCELL_ROW_108_1544 VGND VPWR sky130_fd_sc_hd__tapvpwrvgnd_1
XFILLER_36_164 VGND VGND VPWR VPWR sky130_fd_sc_hd__decap_3
XFILLER_52_613 VGND VGND VPWR VPWR sky130_fd_sc_hd__decap_3
XFILLER_64_495 VGND VGND VPWR VPWR sky130_fd_sc_hd__fill_2
XFILLER_36_197 VGND VGND VPWR VPWR sky130_fd_sc_hd__decap_3
XFILLER_52_657 VGND VGND VPWR VPWR sky130_fd_sc_hd__decap_3
XFILLER_91_292 VGND VGND VPWR VPWR sky130_fd_sc_hd__decap_3
X_4955_ _3526_/B _4639_/A _4950_/A _5033_/B2 VGND VGND VPWR VPWR _4955_/X sky130_fd_sc_hd__a22o_2
XPHY_EDGE_ROW_27_Right_27 VGND VGND VPWR VPWR sky130_fd_sc_hd__decap_3
XFILLER_51_167 VGND VGND VPWR VPWR sky130_fd_sc_hd__fill_1
XFILLER_51_178 VGND VGND VPWR VPWR sky130_fd_sc_hd__decap_3
X_3906_ _6917_/Q _3906_/A2 _5660_/B _6691_/Q VGND VGND VPWR VPWR _3906_/X sky130_fd_sc_hd__a22o_2
XTAP_TAPCELL_ROW_22_516 VGND VPWR sky130_fd_sc_hd__tapvpwrvgnd_1
XFILLER_32_381 VGND VGND VPWR VPWR sky130_fd_sc_hd__fill_2
XFILLER_60_690 VGND VGND VPWR VPWR sky130_fd_sc_hd__fill_2
X_4886_ _4886_/A _4890_/B _4886_/C VGND VGND VPWR VPWR _4886_/X sky130_fd_sc_hd__or3_2
XTAP_TAPCELL_ROW_50_847 VGND VPWR sky130_fd_sc_hd__tapvpwrvgnd_1
X_6625_ _6660_/A VGND VGND VPWR VPWR _6625_/Y sky130_fd_sc_hd__inv_2
X_3837_ _6755_/Q _3656_/Y _3917_/B1 _6767_/Q VGND VGND VPWR VPWR _3837_/X sky130_fd_sc_hd__a22o_2
X_6556_ _6647_/A VGND VGND VPWR VPWR _6556_/Y sky130_fd_sc_hd__inv_2
X_3768_ _6931_/Q _3768_/A2 _3862_/B1 _6795_/Q VGND VGND VPWR VPWR _3768_/X sky130_fd_sc_hd__a22o_2
XFILLER_106_615 VGND VGND VPWR VPWR sky130_fd_sc_hd__decap_3
XFILLER_3_208 VGND VGND VPWR VPWR sky130_fd_sc_hd__decap_3
XFILLER_106_648 VGND VGND VPWR VPWR sky130_fd_sc_hd__decap_3
XFILLER_10_24 VGND VGND VPWR VPWR sky130_fd_sc_hd__decap_3
XFILLER_10_35 VGND VGND VPWR VPWR sky130_fd_sc_hd__decap_3
XFILLER_3_219 VGND VGND VPWR VPWR sky130_fd_sc_hd__decap_3
X_6487_ _6584_/A VGND VGND VPWR VPWR _6487_/Y sky130_fd_sc_hd__inv_2
X_3699_ _6713_/Q _3767_/A2 _3767_/B1 _6891_/Q VGND VGND VPWR VPWR _3699_/X sky130_fd_sc_hd__a22o_2
XFILLER_105_169 VGND VGND VPWR VPWR sky130_fd_sc_hd__fill_1
XFILLER_10_68 VGND VGND VPWR VPWR sky130_fd_sc_hd__decap_3
XPHY_EDGE_ROW_36_Right_36 VGND VGND VPWR VPWR sky130_fd_sc_hd__decap_3
XFILLER_114_681 VGND VGND VPWR VPWR sky130_fd_sc_hd__decap_3
XFILLER_59_212 VGND VGND VPWR VPWR sky130_fd_sc_hd__decap_3
X_5369_ _5369_/A0 _4752_/X _5386_/S VGND VGND VPWR VPWR _7148_/D sky130_fd_sc_hd__mux2_2
XFILLER_99_381 VGND VGND VPWR VPWR sky130_fd_sc_hd__decap_3
XFILLER_101_331 VGND VGND VPWR VPWR sky130_fd_sc_hd__decap_3
XFILLER_19_11 VGND VGND VPWR VPWR sky130_fd_sc_hd__decap_3
X_7108_ _7266_/CLK _7108_/D _6388_/Y VGND VGND VPWR VPWR _7108_/Q sky130_fd_sc_hd__dfrtp_2
XFILLER_101_364 VGND VGND VPWR VPWR sky130_fd_sc_hd__decap_3
XFILLER_19_44 VGND VGND VPWR VPWR sky130_fd_sc_hd__decap_3
XFILLER_59_256 VGND VGND VPWR VPWR sky130_fd_sc_hd__decap_3
X_7039_ _7390_/CLK _7039_/D _6319_/Y VGND VGND VPWR VPWR _7039_/Q sky130_fd_sc_hd__dfrtp_2
XFILLER_74_215 VGND VGND VPWR VPWR sky130_fd_sc_hd__fill_2
XFILLER_74_226 VGND VGND VPWR VPWR sky130_fd_sc_hd__decap_3
XFILLER_74_248 VGND VGND VPWR VPWR sky130_fd_sc_hd__decap_3
XTAP_TAPCELL_ROW_58_947 VGND VPWR sky130_fd_sc_hd__tapvpwrvgnd_1
XFILLER_27_131 VGND VGND VPWR VPWR sky130_fd_sc_hd__decap_3
XTAP_TAPCELL_ROW_2_274 VGND VPWR sky130_fd_sc_hd__tapvpwrvgnd_1
XFILLER_15_326 VGND VGND VPWR VPWR sky130_fd_sc_hd__decap_3
XFILLER_35_43 VGND VGND VPWR VPWR sky130_fd_sc_hd__decap_3
XFILLER_55_484 VGND VGND VPWR VPWR sky130_fd_sc_hd__decap_3
XFILLER_70_421 VGND VGND VPWR VPWR sky130_fd_sc_hd__decap_3
XPHY_EDGE_ROW_45_Right_45 VGND VGND VPWR VPWR sky130_fd_sc_hd__decap_3
XFILLER_15_337 VGND VGND VPWR VPWR sky130_fd_sc_hd__fill_1
XFILLER_35_65 VGND VGND VPWR VPWR sky130_fd_sc_hd__decap_3
XTAP_TAPCELL_ROW_83_1249 VGND VPWR sky130_fd_sc_hd__tapvpwrvgnd_1
XFILLER_30_307 VGND VGND VPWR VPWR sky130_fd_sc_hd__fill_1
XFILLER_43_679 VGND VGND VPWR VPWR sky130_fd_sc_hd__decap_3
XFILLER_70_465 VGND VGND VPWR VPWR sky130_fd_sc_hd__decap_3
XFILLER_70_498 VGND VGND VPWR VPWR sky130_fd_sc_hd__fill_1
XFILLER_11_565 VGND VGND VPWR VPWR sky130_fd_sc_hd__decap_3
XFILLER_51_42 VGND VGND VPWR VPWR sky130_fd_sc_hd__decap_3
XFILLER_109_420 VGND VGND VPWR VPWR sky130_fd_sc_hd__decap_3
XFILLER_109_442 VGND VGND VPWR VPWR sky130_fd_sc_hd__decap_3
XFILLER_51_75 VGND VGND VPWR VPWR sky130_fd_sc_hd__decap_3
XFILLER_51_97 VGND VGND VPWR VPWR sky130_fd_sc_hd__fill_1
XFILLER_7_525 VGND VGND VPWR VPWR sky130_fd_sc_hd__fill_2
XFILLER_7_547 VGND VGND VPWR VPWR sky130_fd_sc_hd__fill_2
XFILLER_109_486 VGND VGND VPWR VPWR sky130_fd_sc_hd__decap_3
XPHY_EDGE_ROW_54_Right_54 VGND VGND VPWR VPWR sky130_fd_sc_hd__decap_3
XFILLER_112_607 VGND VGND VPWR VPWR sky130_fd_sc_hd__decap_3
XTAP_TAPCELL_ROW_94_1378 VGND VPWR sky130_fd_sc_hd__tapvpwrvgnd_1
XFILLER_32_9 VGND VGND VPWR VPWR sky130_fd_sc_hd__fill_1
XFILLER_78_521 VGND VGND VPWR VPWR sky130_fd_sc_hd__decap_3
XFILLER_97_329 VGND VGND VPWR VPWR sky130_fd_sc_hd__decap_3
XFILLER_111_128 VGND VGND VPWR VPWR sky130_fd_sc_hd__decap_3
XFILLER_76_50 VGND VGND VPWR VPWR sky130_fd_sc_hd__decap_3
XFILLER_78_587 VGND VGND VPWR VPWR sky130_fd_sc_hd__fill_1
XFILLER_65_215 VGND VGND VPWR VPWR sky130_fd_sc_hd__decap_3
XFILLER_76_83 VGND VGND VPWR VPWR sky130_fd_sc_hd__fill_1
XFILLER_78_598 VGND VGND VPWR VPWR sky130_fd_sc_hd__decap_3
XPHY_EDGE_ROW_63_Right_63 VGND VGND VPWR VPWR sky130_fd_sc_hd__decap_3
XFILLER_18_186 VGND VGND VPWR VPWR sky130_fd_sc_hd__decap_3
XFILLER_18_197 VGND VGND VPWR VPWR sky130_fd_sc_hd__decap_3
XFILLER_73_281 VGND VGND VPWR VPWR sky130_fd_sc_hd__decap_3
XFILLER_92_60 VGND VGND VPWR VPWR sky130_fd_sc_hd__decap_3
XFILLER_33_167 VGND VGND VPWR VPWR sky130_fd_sc_hd__fill_1
XFILLER_92_82 VGND VGND VPWR VPWR sky130_fd_sc_hd__fill_2
X_4740_ _4745_/A _4765_/B _4611_/Y _4762_/A _4948_/A VGND VGND VPWR VPWR _4740_/X
+ sky130_fd_sc_hd__a221o_2
XTAP_TAPCELL_ROW_103_1485 VGND VPWR sky130_fd_sc_hd__tapvpwrvgnd_1
X_4671_ _6991_/Q _4671_/B VGND VGND VPWR VPWR _4982_/B sky130_fd_sc_hd__and2_2
X_7390_ _7390_/CLK _7390_/D _6670_/Y VGND VGND VPWR VPWR _7390_/Q sky130_fd_sc_hd__dfrtp_2
X_6410_ _6539_/A VGND VGND VPWR VPWR _6410_/Y sky130_fd_sc_hd__inv_2
X_3622_ _4852_/A _5057_/A VGND VGND VPWR VPWR _3635_/B sky130_fd_sc_hd__nand2_2
X_6341_ _6347_/A VGND VGND VPWR VPWR _6341_/Y sky130_fd_sc_hd__inv_2
XPHY_EDGE_ROW_72_Right_72 VGND VGND VPWR VPWR sky130_fd_sc_hd__decap_3
X_3553_ wire568/X _3469_/B _3449_/A _7253_/Q _3365_/A VGND VGND VPWR VPWR _3553_/X
+ sky130_fd_sc_hd__o2111a_2
XFILLER_103_607 VGND VGND VPWR VPWR sky130_fd_sc_hd__fill_1
XFILLER_88_307 VGND VGND VPWR VPWR sky130_fd_sc_hd__fill_1
X_6272_ _6275_/A VGND VGND VPWR VPWR _6272_/Y sky130_fd_sc_hd__inv_2
X_3484_ _4394_/A _4337_/B _3482_/Y _5153_/B VGND VGND VPWR VPWR _3485_/C sky130_fd_sc_hd__o31a_2
XFILLER_103_629 VGND VGND VPWR VPWR sky130_fd_sc_hd__decap_3
XFILLER_88_329 VGND VGND VPWR VPWR sky130_fd_sc_hd__decap_3
X_5223_ _5223_/A _5225_/B VGND VGND VPWR VPWR _7217_/D sky130_fd_sc_hd__and2_2
X_5154_ _5152_/Y _5153_/X _5587_/B VGND VGND VPWR VPWR _5154_/Y sky130_fd_sc_hd__a21oi_2
XFILLER_110_150 VGND VGND VPWR VPWR sky130_fd_sc_hd__decap_3
XFILLER_111_662 VGND VGND VPWR VPWR sky130_fd_sc_hd__decap_3
XFILLER_111_673 VGND VGND VPWR VPWR sky130_fd_sc_hd__decap_3
XFILLER_56_204 VGND VGND VPWR VPWR sky130_fd_sc_hd__fill_1
XFILLER_96_373 VGND VGND VPWR VPWR sky130_fd_sc_hd__decap_3
X_4105_ _7205_/Q _3958_/S _4419_/B1 _7397_/Q _4104_/X VGND VGND VPWR VPWR _4105_/X
+ sky130_fd_sc_hd__a221o_2
XPHY_EDGE_ROW_16_Left_133 VGND VGND VPWR VPWR sky130_fd_sc_hd__decap_3
XFILLER_110_183 VGND VGND VPWR VPWR sky130_fd_sc_hd__decap_3
XFILLER_2_80 VGND VGND VPWR VPWR sky130_fd_sc_hd__decap_3
X_5085_ _5086_/A _5084_/B _5084_/X VGND VGND VPWR VPWR _5085_/X sky130_fd_sc_hd__o21ba_2
XPHY_EDGE_ROW_81_Right_81 VGND VGND VPWR VPWR sky130_fd_sc_hd__decap_3
XFILLER_2_91 VGND VGND VPWR VPWR sky130_fd_sc_hd__decap_3
XFILLER_56_248 VGND VGND VPWR VPWR sky130_fd_sc_hd__decap_3
XFILLER_56_259 VGND VGND VPWR VPWR sky130_fd_sc_hd__decap_3
XFILLER_84_568 VGND VGND VPWR VPWR sky130_fd_sc_hd__fill_1
X_4036_ _7310_/Q _4837_/S _4434_/A2 _7118_/Q _4035_/X VGND VGND VPWR VPWR _4036_/X
+ sky130_fd_sc_hd__a221o_2
XTAP_TAPCELL_ROW_55_917 VGND VPWR sky130_fd_sc_hd__tapvpwrvgnd_1
XTAP_TAPCELL_ROW_55_906 VGND VPWR sky130_fd_sc_hd__tapvpwrvgnd_1
XFILLER_112_26 VGND VGND VPWR VPWR sky130_fd_sc_hd__fill_2
XFILLER_112_59 VGND VGND VPWR VPWR sky130_fd_sc_hd__decap_3
XFILLER_24_112 VGND VGND VPWR VPWR sky130_fd_sc_hd__decap_3
XFILLER_25_657 VGND VGND VPWR VPWR sky130_fd_sc_hd__decap_3
XFILLER_52_421 VGND VGND VPWR VPWR sky130_fd_sc_hd__decap_3
XTAP_TAPCELL_ROW_69_1082 VGND VPWR sky130_fd_sc_hd__tapvpwrvgnd_1
XFILLER_12_307 VGND VGND VPWR VPWR sky130_fd_sc_hd__fill_1
XFILLER_12_318 VGND VGND VPWR VPWR sky130_fd_sc_hd__fill_2
XTAP_TAPCELL_ROW_35_674 VGND VPWR sky130_fd_sc_hd__tapvpwrvgnd_1
X_4938_ _4938_/A _4938_/B VGND VGND VPWR VPWR _4938_/Y sky130_fd_sc_hd__nor2_2
X_4869_ _6999_/Q _4858_/B _5570_/A2 VGND VGND VPWR VPWR _4870_/B sky130_fd_sc_hd__o21ai_2
XPHY_EDGE_ROW_25_Left_142 VGND VGND VPWR VPWR sky130_fd_sc_hd__decap_3
XFILLER_20_362 VGND VGND VPWR VPWR sky130_fd_sc_hd__fill_2
XFILLER_21_12 VGND VGND VPWR VPWR sky130_fd_sc_hd__decap_3
X_6608_ _6608_/A VGND VGND VPWR VPWR _6608_/Y sky130_fd_sc_hd__inv_2
XPHY_EDGE_ROW_90_Right_90 VGND VGND VPWR VPWR sky130_fd_sc_hd__decap_3
XFILLER_106_401 VGND VGND VPWR VPWR sky130_fd_sc_hd__decap_3
XFILLER_4_539 VGND VGND VPWR VPWR sky130_fd_sc_hd__fill_2
X_6539_ _6539_/A VGND VGND VPWR VPWR _6539_/Y sky130_fd_sc_hd__inv_2
XFILLER_106_445 VGND VGND VPWR VPWR sky130_fd_sc_hd__decap_3
XFILLER_97_27 VGND VGND VPWR VPWR sky130_fd_sc_hd__decap_3
XFILLER_79_318 VGND VGND VPWR VPWR sky130_fd_sc_hd__decap_3
XTAP_TAPCELL_ROW_7_333 VGND VPWR sky130_fd_sc_hd__tapvpwrvgnd_1
XPHY_EDGE_ROW_34_Left_151 VGND VGND VPWR VPWR sky130_fd_sc_hd__decap_3
XFILLER_102_651 VGND VGND VPWR VPWR sky130_fd_sc_hd__decap_3
XFILLER_75_502 VGND VGND VPWR VPWR sky130_fd_sc_hd__fill_2
XFILLER_87_340 VGND VGND VPWR VPWR sky130_fd_sc_hd__decap_3
XFILLER_101_172 VGND VGND VPWR VPWR sky130_fd_sc_hd__decap_3
XFILLER_102_684 VGND VGND VPWR VPWR sky130_fd_sc_hd__decap_3
XFILLER_46_20 VGND VGND VPWR VPWR sky130_fd_sc_hd__decap_3
XFILLER_16_613 VGND VGND VPWR VPWR sky130_fd_sc_hd__decap_3
XFILLER_46_53 VGND VGND VPWR VPWR sky130_fd_sc_hd__decap_3
XFILLER_16_657 VGND VGND VPWR VPWR sky130_fd_sc_hd__decap_3
XFILLER_55_281 VGND VGND VPWR VPWR sky130_fd_sc_hd__decap_3
XFILLER_102_70 VGND VGND VPWR VPWR sky130_fd_sc_hd__decap_3
XFILLER_15_167 VGND VGND VPWR VPWR sky130_fd_sc_hd__fill_1
XFILLER_43_487 VGND VGND VPWR VPWR sky130_fd_sc_hd__fill_2
XFILLER_70_295 VGND VGND VPWR VPWR sky130_fd_sc_hd__decap_3
XPHY_EDGE_ROW_43_Left_160 VGND VGND VPWR VPWR sky130_fd_sc_hd__decap_3
XFILLER_11_340 VGND VGND VPWR VPWR sky130_fd_sc_hd__fill_2
XFILLER_62_85 VGND VGND VPWR VPWR sky130_fd_sc_hd__decap_3
XFILLER_11_384 VGND VGND VPWR VPWR sky130_fd_sc_hd__fill_1
XFILLER_7_36 VGND VGND VPWR VPWR sky130_fd_sc_hd__decap_3
XTAP_TAPCELL_ROW_96_1407 VGND VPWR sky130_fd_sc_hd__tapvpwrvgnd_1
XFILLER_116_209 VGND VGND VPWR VPWR sky130_fd_sc_hd__decap_3
XFILLER_7_355 VGND VGND VPWR VPWR sky130_fd_sc_hd__decap_3
XFILLER_7_69 VGND VGND VPWR VPWR sky130_fd_sc_hd__decap_3
XFILLER_109_272 VGND VGND VPWR VPWR sky130_fd_sc_hd__decap_3
XFILLER_7_388 VGND VGND VPWR VPWR sky130_fd_sc_hd__fill_1
XFILLER_7_399 VGND VGND VPWR VPWR sky130_fd_sc_hd__decap_3
XFILLER_98_627 VGND VGND VPWR VPWR sky130_fd_sc_hd__decap_3
XFILLER_87_60 VGND VGND VPWR VPWR sky130_fd_sc_hd__decap_3
XFILLER_97_126 VGND VGND VPWR VPWR sky130_fd_sc_hd__decap_3
XFILLER_97_148 VGND VGND VPWR VPWR sky130_fd_sc_hd__fill_2
XFILLER_87_82 VGND VGND VPWR VPWR sky130_fd_sc_hd__decap_3
XFILLER_78_395 VGND VGND VPWR VPWR sky130_fd_sc_hd__decap_3
XFILLER_38_259 VGND VGND VPWR VPWR sky130_fd_sc_hd__decap_3
XFILLER_81_505 VGND VGND VPWR VPWR sky130_fd_sc_hd__decap_3
XFILLER_19_484 VGND VGND VPWR VPWR sky130_fd_sc_hd__fill_2
XFILLER_81_538 VGND VGND VPWR VPWR sky130_fd_sc_hd__fill_2
XFILLER_93_387 VGND VGND VPWR VPWR sky130_fd_sc_hd__decap_3
XTAP_TAPCELL_ROW_105_1514 VGND VPWR sky130_fd_sc_hd__tapvpwrvgnd_1
XFILLER_34_421 VGND VGND VPWR VPWR sky130_fd_sc_hd__fill_2
XFILLER_46_281 VGND VGND VPWR VPWR sky130_fd_sc_hd__decap_3
X_6890_ _7405_/CLK _6890_/D VGND VGND VPWR VPWR _6890_/Q sky130_fd_sc_hd__dfxtp_2
XTAP_TAPCELL_ROW_32_633 VGND VPWR sky130_fd_sc_hd__tapvpwrvgnd_1
XFILLER_21_159 VGND VGND VPWR VPWR sky130_fd_sc_hd__decap_3
X_4723_ _3536_/B _4720_/A _4721_/Y _3526_/B VGND VGND VPWR VPWR _4723_/X sky130_fd_sc_hd__a22o_2
XTAP_TAPCELL_ROW_60_975 VGND VPWR sky130_fd_sc_hd__tapvpwrvgnd_1
X_4654_ _4646_/Y _4647_/X _4653_/Y _4788_/B VGND VGND VPWR VPWR _4762_/A sky130_fd_sc_hd__a211o_2
XTAP_TAPCELL_ROW_12_390 VGND VPWR sky130_fd_sc_hd__tapvpwrvgnd_1
X_7373_ _7403_/CLK _7373_/D _6653_/Y VGND VGND VPWR VPWR _7373_/Q sky130_fd_sc_hd__dfrtp_2
Xhold801 _6790_/Q VGND VGND VPWR VPWR _6790_/D sky130_fd_sc_hd__dlygate4sd3_1
Xhold812 _6967_/Q VGND VGND VPWR VPWR _6967_/D sky130_fd_sc_hd__dlygate4sd3_1
X_4585_ _4585_/A _4595_/B VGND VGND VPWR VPWR _7288_/D sky130_fd_sc_hd__and2_2
X_3605_ _3621_/A _3621_/B VGND VGND VPWR VPWR _3605_/Y sky130_fd_sc_hd__nor2b_2
XTAP_TAPCELL_ROW_116_1643 VGND VPWR sky130_fd_sc_hd__tapvpwrvgnd_1
XFILLER_115_220 VGND VGND VPWR VPWR sky130_fd_sc_hd__decap_3
XFILLER_115_231 VGND VGND VPWR VPWR sky130_fd_sc_hd__decap_3
Xhold823 _6770_/Q VGND VGND VPWR VPWR _6770_/D sky130_fd_sc_hd__dlygate4sd3_1
Xhold834 _6950_/Q VGND VGND VPWR VPWR _6950_/D sky130_fd_sc_hd__dlygate4sd3_1
Xhold845 _7061_/Q VGND VGND VPWR VPWR _7061_/D sky130_fd_sc_hd__dlygate4sd3_1
X_6324_ _6642_/A VGND VGND VPWR VPWR _6324_/Y sky130_fd_sc_hd__inv_2
X_3536_ _4614_/A _3536_/B VGND VGND VPWR VPWR _3536_/Y sky130_fd_sc_hd__nand2_2
XTAP_TAPCELL_ROW_116_1654 VGND VPWR sky130_fd_sc_hd__tapvpwrvgnd_1
XFILLER_107_26 VGND VGND VPWR VPWR sky130_fd_sc_hd__decap_3
XFILLER_115_264 VGND VGND VPWR VPWR sky130_fd_sc_hd__decap_3
XFILLER_89_638 VGND VGND VPWR VPWR sky130_fd_sc_hd__decap_3
Xhold856 _7073_/Q VGND VGND VPWR VPWR _7073_/D sky130_fd_sc_hd__dlygate4sd3_1
Xhold867 _7095_/Q VGND VGND VPWR VPWR _7095_/D sky130_fd_sc_hd__dlygate4sd3_1
Xhold878 _7062_/Q VGND VGND VPWR VPWR _7062_/D sky130_fd_sc_hd__dlygate4sd3_1
Xhold889 _7079_/Q VGND VGND VPWR VPWR _7079_/D sky130_fd_sc_hd__dlygate4sd3_1
Xmax_cap564 _4634_/D VGND VGND VPWR VPWR _4950_/A sky130_fd_sc_hd__clkbuf_2
XFILLER_88_126 VGND VGND VPWR VPWR sky130_fd_sc_hd__decap_3
X_3467_ _7121_/Q _4351_/B1 _4334_/B1 _7153_/Q _3466_/X VGND VGND VPWR VPWR _3467_/X
+ sky130_fd_sc_hd__a221o_2
XFILLER_57_502 VGND VGND VPWR VPWR sky130_fd_sc_hd__fill_2
XFILLER_69_351 VGND VGND VPWR VPWR sky130_fd_sc_hd__decap_3
X_3398_ _4528_/B VGND VGND VPWR VPWR _3398_/Y sky130_fd_sc_hd__inv_2
XTAP_TAPCELL_ROW_4_303 VGND VPWR sky130_fd_sc_hd__tapvpwrvgnd_1
XFILLER_97_671 VGND VGND VPWR VPWR sky130_fd_sc_hd__fill_1
XFILLER_57_513 VGND VGND VPWR VPWR sky130_fd_sc_hd__decap_3
XFILLER_57_535 VGND VGND VPWR VPWR sky130_fd_sc_hd__decap_3
XFILLER_97_682 VGND VGND VPWR VPWR sky130_fd_sc_hd__decap_3
XFILLER_111_492 VGND VGND VPWR VPWR sky130_fd_sc_hd__decap_3
XFILLER_29_248 VGND VGND VPWR VPWR sky130_fd_sc_hd__decap_3
XFILLER_57_557 VGND VGND VPWR VPWR sky130_fd_sc_hd__decap_3
XFILLER_57_579 VGND VGND VPWR VPWR sky130_fd_sc_hd__decap_3
X_5068_ _6985_/Q _6986_/Q _5068_/C VGND VGND VPWR VPWR _5069_/B sky130_fd_sc_hd__and3_2
XFILLER_44_207 VGND VGND VPWR VPWR sky130_fd_sc_hd__decap_3
XFILLER_83_18 VGND VGND VPWR VPWR sky130_fd_sc_hd__decap_3
XFILLER_84_365 VGND VGND VPWR VPWR sky130_fd_sc_hd__decap_3
X_4019_ _7278_/Q _4437_/A2 _4430_/A2 _7246_/Q _4018_/X VGND VGND VPWR VPWR _4019_/X
+ sky130_fd_sc_hd__a221o_2
XFILLER_16_12 VGND VGND VPWR VPWR sky130_fd_sc_hd__decap_3
XFILLER_25_432 VGND VGND VPWR VPWR sky130_fd_sc_hd__decap_3
XFILLER_16_56 VGND VGND VPWR VPWR sky130_fd_sc_hd__decap_3
XFILLER_52_240 VGND VGND VPWR VPWR sky130_fd_sc_hd__fill_1
XTAP_TAPCELL_ROW_80_1208 VGND VPWR sky130_fd_sc_hd__tapvpwrvgnd_1
XPHY_EDGE_ROW_0_Right_0 VGND VGND VPWR VPWR sky130_fd_sc_hd__decap_3
XFILLER_12_104 VGND VGND VPWR VPWR sky130_fd_sc_hd__decap_3
XFILLER_25_487 VGND VGND VPWR VPWR sky130_fd_sc_hd__decap_3
XFILLER_25_498 VGND VGND VPWR VPWR sky130_fd_sc_hd__decap_3
XFILLER_40_424 VGND VGND VPWR VPWR sky130_fd_sc_hd__decap_3
XFILLER_80_582 VGND VGND VPWR VPWR sky130_fd_sc_hd__decap_3
XFILLER_12_159 VGND VGND VPWR VPWR sky130_fd_sc_hd__decap_3
XFILLER_32_22 VGND VGND VPWR VPWR sky130_fd_sc_hd__decap_3
XFILLER_40_446 VGND VGND VPWR VPWR sky130_fd_sc_hd__decap_3
XFILLER_113_3 VGND VGND VPWR VPWR sky130_fd_sc_hd__decap_3
XFILLER_4_325 VGND VGND VPWR VPWR sky130_fd_sc_hd__decap_3
XFILLER_106_231 VGND VGND VPWR VPWR sky130_fd_sc_hd__decap_3
XFILLER_106_242 VGND VGND VPWR VPWR sky130_fd_sc_hd__decap_3
XFILLER_106_253 VGND VGND VPWR VPWR sky130_fd_sc_hd__decap_3
XFILLER_79_104 VGND VGND VPWR VPWR sky130_fd_sc_hd__decap_3
XFILLER_106_286 VGND VGND VPWR VPWR sky130_fd_sc_hd__decap_3
XTAP_TAPCELL_ROW_91_1348 VGND VPWR sky130_fd_sc_hd__tapvpwrvgnd_1
XFILLER_0_564 VGND VGND VPWR VPWR sky130_fd_sc_hd__fill_2
XFILLER_88_660 VGND VGND VPWR VPWR sky130_fd_sc_hd__decap_3
XFILLER_95_608 VGND VGND VPWR VPWR sky130_fd_sc_hd__decap_3
XFILLER_0_586 VGND VGND VPWR VPWR sky130_fd_sc_hd__fill_2
XFILLER_94_129 VGND VGND VPWR VPWR sky130_fd_sc_hd__decap_3
XFILLER_48_568 VGND VGND VPWR VPWR sky130_fd_sc_hd__decap_3
XFILLER_75_332 VGND VGND VPWR VPWR sky130_fd_sc_hd__decap_3
XFILLER_75_343 VGND VGND VPWR VPWR sky130_fd_sc_hd__decap_3
XFILLER_63_505 VGND VGND VPWR VPWR sky130_fd_sc_hd__decap_3
XFILLER_63_527 VGND VGND VPWR VPWR sky130_fd_sc_hd__decap_3
XFILLER_90_313 VGND VGND VPWR VPWR sky130_fd_sc_hd__decap_3
XFILLER_28_292 VGND VGND VPWR VPWR sky130_fd_sc_hd__decap_3
XFILLER_73_40 VGND VGND VPWR VPWR sky130_fd_sc_hd__fill_1
XFILLER_90_368 VGND VGND VPWR VPWR sky130_fd_sc_hd__fill_1
XFILLER_31_435 VGND VGND VPWR VPWR sky130_fd_sc_hd__decap_3
XFILLER_43_284 VGND VGND VPWR VPWR sky130_fd_sc_hd__decap_3
XFILLER_73_84 VGND VGND VPWR VPWR sky130_fd_sc_hd__decap_3
XFILLER_12_671 VGND VGND VPWR VPWR sky130_fd_sc_hd__decap_3
XTAP_TAPCELL_ROW_100_1455 VGND VPWR sky130_fd_sc_hd__tapvpwrvgnd_1
XFILLER_78_6 VGND VGND VPWR VPWR sky130_fd_sc_hd__decap_3
XFILLER_8_653 VGND VGND VPWR VPWR sky130_fd_sc_hd__decap_3
XFILLER_7_152 VGND VGND VPWR VPWR sky130_fd_sc_hd__decap_3
X_4370_ _5100_/B _4361_/X _4362_/X _4369_/Y VGND VGND VPWR VPWR _5032_/B sky130_fd_sc_hd__a211o_2
X_3321_ _3371_/A _3365_/A VGND VGND VPWR VPWR _5294_/A sky130_fd_sc_hd__or2_4
XFILLER_112_212 VGND VGND VPWR VPWR sky130_fd_sc_hd__decap_3
XFILLER_98_435 VGND VGND VPWR VPWR sky130_fd_sc_hd__decap_3
XFILLER_100_407 VGND VGND VPWR VPWR sky130_fd_sc_hd__decap_3
XFILLER_112_245 VGND VGND VPWR VPWR sky130_fd_sc_hd__decap_3
XFILLER_79_671 VGND VGND VPWR VPWR sky130_fd_sc_hd__fill_1
XFILLER_79_682 VGND VGND VPWR VPWR sky130_fd_sc_hd__decap_3
XFILLER_94_630 VGND VGND VPWR VPWR sky130_fd_sc_hd__decap_3
XTAP_TAPCELL_ROW_111_1584 VGND VPWR sky130_fd_sc_hd__tapvpwrvgnd_1
XFILLER_66_332 VGND VGND VPWR VPWR sky130_fd_sc_hd__decap_3
XFILLER_94_663 VGND VGND VPWR VPWR sky130_fd_sc_hd__decap_3
XFILLER_26_218 VGND VGND VPWR VPWR sky130_fd_sc_hd__decap_3
XFILLER_66_365 VGND VGND VPWR VPWR sky130_fd_sc_hd__decap_3
XFILLER_66_387 VGND VGND VPWR VPWR sky130_fd_sc_hd__decap_3
XFILLER_19_281 VGND VGND VPWR VPWR sky130_fd_sc_hd__decap_3
XFILLER_81_335 VGND VGND VPWR VPWR sky130_fd_sc_hd__fill_1
X_6942_ _6944_/CLK _6942_/D VGND VGND VPWR VPWR _6942_/Q sky130_fd_sc_hd__dfxtp_2
XFILLER_34_240 VGND VGND VPWR VPWR sky130_fd_sc_hd__decap_3
X_6873_ clkload2/A _6873_/D VGND VGND VPWR VPWR _6873_/Q sky130_fd_sc_hd__dfxtp_2
XTAP_TAPCELL_ROW_66_1041 VGND VPWR sky130_fd_sc_hd__tapvpwrvgnd_1
XFILLER_62_582 VGND VGND VPWR VPWR sky130_fd_sc_hd__decap_3
XTAP_TAPCELL_ROW_45_791 VGND VPWR sky130_fd_sc_hd__tapvpwrvgnd_1
XTAP_TAPCELL_ROW_17_460 VGND VPWR sky130_fd_sc_hd__tapvpwrvgnd_1
XFILLER_10_608 VGND VGND VPWR VPWR sky130_fd_sc_hd__fill_2
X_5686_ _7349_/Q hold908/X _5706_/S VGND VGND VPWR VPWR _5686_/X sky130_fd_sc_hd__mux2_2
X_4706_ _6997_/Q _4931_/A VGND VGND VPWR VPWR _4912_/A sky130_fd_sc_hd__and2_2
X_4637_ _4380_/B _4637_/B _4637_/C VGND VGND VPWR VPWR _4950_/B sky130_fd_sc_hd__and3b_2
Xhold620 _6872_/Q VGND VGND VPWR VPWR _6872_/D sky130_fd_sc_hd__dlygate4sd3_1
XFILLER_116_551 VGND VGND VPWR VPWR sky130_fd_sc_hd__decap_3
XFILLER_89_402 VGND VGND VPWR VPWR sky130_fd_sc_hd__decap_3
X_7356_ _7360_/CLK _7356_/D _6636_/Y VGND VGND VPWR VPWR _7356_/Q sky130_fd_sc_hd__dfrtp_2
Xhold631 _6927_/Q VGND VGND VPWR VPWR _6927_/D sky130_fd_sc_hd__dlygate4sd3_1
Xhold642 _6971_/Q VGND VGND VPWR VPWR _6971_/D sky130_fd_sc_hd__dlygate4sd3_1
Xhold653 _6792_/Q VGND VGND VPWR VPWR _6792_/D sky130_fd_sc_hd__dlygate4sd3_1
XTAP_TAPCELL_ROW_77_1181 VGND VPWR sky130_fd_sc_hd__tapvpwrvgnd_1
XTAP_TAPCELL_ROW_77_1170 VGND VPWR sky130_fd_sc_hd__tapvpwrvgnd_1
XFILLER_103_201 VGND VGND VPWR VPWR sky130_fd_sc_hd__decap_3
XFILLER_103_223 VGND VGND VPWR VPWR sky130_fd_sc_hd__fill_1
XFILLER_116_595 VGND VGND VPWR VPWR sky130_fd_sc_hd__decap_3
X_7287_ clkload5/A _7287_/D _6567_/Y VGND VGND VPWR VPWR _7287_/Q sky130_fd_sc_hd__dfrtp_2
Xhold664 _6788_/Q VGND VGND VPWR VPWR _6788_/D sky130_fd_sc_hd__dlygate4sd3_1
Xhold675 _6727_/Q VGND VGND VPWR VPWR _6727_/D sky130_fd_sc_hd__dlygate4sd3_1
Xhold686 _6938_/Q VGND VGND VPWR VPWR _6938_/D sky130_fd_sc_hd__dlygate4sd3_1
Xhold697 _6743_/Q VGND VGND VPWR VPWR _6743_/D sky130_fd_sc_hd__dlygate4sd3_1
X_6307_ _6525_/A VGND VGND VPWR VPWR _6307_/Y sky130_fd_sc_hd__inv_2
X_4499_ _4499_/A0 _4565_/A _4501_/S VGND VGND VPWR VPWR _7330_/D sky130_fd_sc_hd__mux2_2
X_3519_ _6979_/Q _3519_/B VGND VGND VPWR VPWR _3519_/Y sky130_fd_sc_hd__nor2_2
XFILLER_103_278 VGND VGND VPWR VPWR sky130_fd_sc_hd__fill_2
XFILLER_57_310 VGND VGND VPWR VPWR sky130_fd_sc_hd__decap_3
XFILLER_57_343 VGND VGND VPWR VPWR sky130_fd_sc_hd__decap_3
XFILLER_69_181 VGND VGND VPWR VPWR sky130_fd_sc_hd__decap_3
XFILLER_85_641 VGND VGND VPWR VPWR sky130_fd_sc_hd__decap_3
XFILLER_17_207 VGND VGND VPWR VPWR sky130_fd_sc_hd__decap_3
XFILLER_27_33 VGND VGND VPWR VPWR sky130_fd_sc_hd__decap_3
XFILLER_57_376 VGND VGND VPWR VPWR sky130_fd_sc_hd__decap_3
XFILLER_84_162 VGND VGND VPWR VPWR sky130_fd_sc_hd__decap_3
XFILLER_85_685 VGND VGND VPWR VPWR sky130_fd_sc_hd__decap_3
XFILLER_27_66 VGND VGND VPWR VPWR sky130_fd_sc_hd__decap_3
XFILLER_72_324 VGND VGND VPWR VPWR sky130_fd_sc_hd__decap_3
XFILLER_84_195 VGND VGND VPWR VPWR sky130_fd_sc_hd__fill_1
XFILLER_27_99 VGND VGND VPWR VPWR sky130_fd_sc_hd__decap_3
XFILLER_72_357 VGND VGND VPWR VPWR sky130_fd_sc_hd__decap_3
XFILLER_72_379 VGND VGND VPWR VPWR sky130_fd_sc_hd__decap_3
XFILLER_25_273 VGND VGND VPWR VPWR sky130_fd_sc_hd__decap_3
XFILLER_43_21 VGND VGND VPWR VPWR sky130_fd_sc_hd__decap_3
XFILLER_13_446 VGND VGND VPWR VPWR sky130_fd_sc_hd__fill_2
XFILLER_25_295 VGND VGND VPWR VPWR sky130_fd_sc_hd__decap_3
Xclkbuf_leaf_20_clk clkbuf_3_6__f_clk/X VGND VGND VPWR VPWR _7406_/CLK sky130_fd_sc_hd__clkbuf_16
XFILLER_5_612 VGND VGND VPWR VPWR sky130_fd_sc_hd__decap_3
XFILLER_5_623 VGND VGND VPWR VPWR sky130_fd_sc_hd__fill_2
XFILLER_4_100 VGND VGND VPWR VPWR sky130_fd_sc_hd__decap_3
XFILLER_4_133 VGND VGND VPWR VPWR sky130_fd_sc_hd__decap_3
XFILLER_4_144 VGND VGND VPWR VPWR sky130_fd_sc_hd__decap_3
XFILLER_4_15 VGND VGND VPWR VPWR sky130_fd_sc_hd__decap_3
XFILLER_108_80 VGND VGND VPWR VPWR sky130_fd_sc_hd__decap_3
XFILLER_4_59 VGND VGND VPWR VPWR sky130_fd_sc_hd__decap_3
XFILLER_108_91 VGND VGND VPWR VPWR sky130_fd_sc_hd__decap_3
XFILLER_95_405 VGND VGND VPWR VPWR sky130_fd_sc_hd__decap_3
XFILLER_0_350 VGND VGND VPWR VPWR sky130_fd_sc_hd__decap_3
XFILLER_95_449 VGND VGND VPWR VPWR sky130_fd_sc_hd__decap_3
XFILLER_48_354 VGND VGND VPWR VPWR sky130_fd_sc_hd__fill_2
XFILLER_48_365 VGND VGND VPWR VPWR sky130_fd_sc_hd__decap_3
XFILLER_63_302 VGND VGND VPWR VPWR sky130_fd_sc_hd__decap_3
XFILLER_76_663 VGND VGND VPWR VPWR sky130_fd_sc_hd__decap_3
XFILLER_48_398 VGND VGND VPWR VPWR sky130_fd_sc_hd__decap_3
XFILLER_75_184 VGND VGND VPWR VPWR sky130_fd_sc_hd__decap_3
XFILLER_84_61 VGND VGND VPWR VPWR sky130_fd_sc_hd__decap_3
XFILLER_91_644 VGND VGND VPWR VPWR sky130_fd_sc_hd__decap_3
Xplace313 _5274_/S VGND VGND VPWR VPWR _5262_/S sky130_fd_sc_hd__buf_2
Xplace302 _4811_/C VGND VGND VPWR VPWR _5146_/B1 sky130_fd_sc_hd__buf_2
XFILLER_51_519 VGND VGND VPWR VPWR sky130_fd_sc_hd__fill_1
XFILLER_90_165 VGND VGND VPWR VPWR sky130_fd_sc_hd__decap_3
XFILLER_91_688 VGND VGND VPWR VPWR sky130_fd_sc_hd__decap_3
Xplace346 _4272_/B VGND VGND VPWR VPWR _4394_/B sky130_fd_sc_hd__buf_2
Xplace335 _4349_/B1 VGND VGND VPWR VPWR _4430_/A2 sky130_fd_sc_hd__buf_2
Xplace324 _4205_/A VGND VGND VPWR VPWR _4432_/B1 sky130_fd_sc_hd__buf_2
XFILLER_16_262 VGND VGND VPWR VPWR sky130_fd_sc_hd__fill_2
XFILLER_16_273 VGND VGND VPWR VPWR sky130_fd_sc_hd__decap_3
Xplace379 _4348_/B1 VGND VGND VPWR VPWR _4303_/B1 sky130_fd_sc_hd__buf_2
Xplace368 _3388_/Y VGND VGND VPWR VPWR _4347_/C1 sky130_fd_sc_hd__buf_2
Xplace357 _5159_/S VGND VGND VPWR VPWR _4946_/S sky130_fd_sc_hd__buf_2
XFILLER_31_243 VGND VGND VPWR VPWR sky130_fd_sc_hd__decap_3
X_3870_ _6760_/Q _3883_/A2 _3913_/B1 _6754_/Q _3869_/X VGND VGND VPWR VPWR _3870_/X
+ sky130_fd_sc_hd__a221o_2
XTAP_TAPCELL_ROW_42_761 VGND VPWR sky130_fd_sc_hd__tapvpwrvgnd_1
XTAP_TAPCELL_ROW_42_750 VGND VPWR sky130_fd_sc_hd__tapvpwrvgnd_1
XFILLER_76_3 VGND VGND VPWR VPWR sky130_fd_sc_hd__decap_3
Xclkbuf_leaf_11_clk clkbuf_leaf_4_clk/A VGND VGND VPWR VPWR _7398_/CLK sky130_fd_sc_hd__clkbuf_16
XFILLER_8_483 VGND VGND VPWR VPWR sky130_fd_sc_hd__fill_1
X_7210_ _7234_/CLK _7210_/D _6490_/Y VGND VGND VPWR VPWR _7210_/Q sky130_fd_sc_hd__dfrtp_2
X_4422_ _7272_/Q _4422_/A2 _4419_/X _4421_/X VGND VGND VPWR VPWR _4422_/X sky130_fd_sc_hd__a211o_2
XTAP_TAPCELL_ROW_113_1613 VGND VPWR sky130_fd_sc_hd__tapvpwrvgnd_1
XTAP_TAPCELL_ROW_113_1602 VGND VPWR sky130_fd_sc_hd__tapvpwrvgnd_1
XFILLER_113_532 VGND VGND VPWR VPWR sky130_fd_sc_hd__decap_3
X_7141_ _7368_/CLK _7141_/D _6421_/Y VGND VGND VPWR VPWR _7141_/Q sky130_fd_sc_hd__dfrtp_2
X_4353_ _7225_/Q _4469_/A3 _3968_/S _7193_/Q VGND VGND VPWR VPWR _4355_/A sky130_fd_sc_hd__a22o_2
XFILLER_59_608 VGND VGND VPWR VPWR sky130_fd_sc_hd__decap_3
X_7072_ _7265_/CLK _7072_/D _6352_/Y VGND VGND VPWR VPWR _7072_/Q sky130_fd_sc_hd__dfrtp_2
X_4284_ _7222_/Q _4331_/A2 _3987_/S _7190_/Q VGND VGND VPWR VPWR _4286_/A sky130_fd_sc_hd__a22o_2
X_3304_ _5129_/A _3353_/A VGND VGND VPWR VPWR _4696_/B sky130_fd_sc_hd__nand2_2
XFILLER_113_576 VGND VGND VPWR VPWR sky130_fd_sc_hd__decap_3
XFILLER_98_287 VGND VGND VPWR VPWR sky130_fd_sc_hd__decap_3
XFILLER_100_259 VGND VGND VPWR VPWR sky130_fd_sc_hd__decap_3
XFILLER_104_27 VGND VGND VPWR VPWR sky130_fd_sc_hd__fill_1
XFILLER_67_641 VGND VGND VPWR VPWR sky130_fd_sc_hd__decap_3
XFILLER_79_490 VGND VGND VPWR VPWR sky130_fd_sc_hd__decap_3
XFILLER_27_505 VGND VGND VPWR VPWR sky130_fd_sc_hd__fill_2
XFILLER_39_376 VGND VGND VPWR VPWR sky130_fd_sc_hd__decap_3
XFILLER_54_302 VGND VGND VPWR VPWR sky130_fd_sc_hd__decap_3
XFILLER_66_162 VGND VGND VPWR VPWR sky130_fd_sc_hd__decap_3
XFILLER_67_685 VGND VGND VPWR VPWR sky130_fd_sc_hd__decap_3
XFILLER_54_324 VGND VGND VPWR VPWR sky130_fd_sc_hd__fill_2
XFILLER_66_195 VGND VGND VPWR VPWR sky130_fd_sc_hd__fill_1
XFILLER_82_622 VGND VGND VPWR VPWR sky130_fd_sc_hd__decap_3
XFILLER_94_482 VGND VGND VPWR VPWR sky130_fd_sc_hd__fill_2
XFILLER_54_368 VGND VGND VPWR VPWR sky130_fd_sc_hd__fill_1
XFILLER_81_143 VGND VGND VPWR VPWR sky130_fd_sc_hd__decap_3
XFILLER_82_666 VGND VGND VPWR VPWR sky130_fd_sc_hd__decap_3
X_6925_ _6975_/CLK _6925_/D VGND VGND VPWR VPWR _6925_/Q sky130_fd_sc_hd__dfxtp_2
XFILLER_81_187 VGND VGND VPWR VPWR sky130_fd_sc_hd__fill_2
XFILLER_81_198 VGND VGND VPWR VPWR sky130_fd_sc_hd__fill_1
XFILLER_22_243 VGND VGND VPWR VPWR sky130_fd_sc_hd__decap_3
XFILLER_50_541 VGND VGND VPWR VPWR sky130_fd_sc_hd__fill_2
XFILLER_62_390 VGND VGND VPWR VPWR sky130_fd_sc_hd__fill_1
Xfanout25 _6664_/A VGND VGND VPWR VPWR _6635_/A sky130_fd_sc_hd__buf_2
Xfanout36 _6644_/A VGND VGND VPWR VPWR _6608_/A sky130_fd_sc_hd__buf_2
Xfanout47 fanout51/X VGND VGND VPWR VPWR _6643_/A sky130_fd_sc_hd__clkdlybuf4s25_1
X_6856_ _6944_/CLK _6856_/D VGND VGND VPWR VPWR _6856_/Q sky130_fd_sc_hd__dfxtp_2
XFILLER_22_276 VGND VGND VPWR VPWR sky130_fd_sc_hd__decap_3
Xfanout58 reset VGND VGND VPWR VPWR _6288_/A sky130_fd_sc_hd__buf_1
Xfanout69 _6523_/A VGND VGND VPWR VPWR _6553_/A sky130_fd_sc_hd__buf_2
X_6787_ _7392_/CLK _6787_/D VGND VGND VPWR VPWR _6787_/Q sky130_fd_sc_hd__dfxtp_2
XFILLER_13_35 VGND VGND VPWR VPWR sky130_fd_sc_hd__decap_3
XFILLER_13_57 VGND VGND VPWR VPWR sky130_fd_sc_hd__decap_3
XFILLER_108_304 VGND VGND VPWR VPWR sky130_fd_sc_hd__decap_3
XTAP_TAPCELL_ROW_20_488 VGND VPWR sky130_fd_sc_hd__tapvpwrvgnd_1
XFILLER_2_604 VGND VGND VPWR VPWR sky130_fd_sc_hd__decap_3
XFILLER_1_125 VGND VGND VPWR VPWR sky130_fd_sc_hd__decap_3
XFILLER_2_648 VGND VGND VPWR VPWR sky130_fd_sc_hd__decap_3
X_7339_ _7372_/CLK _7339_/D _6619_/Y VGND VGND VPWR VPWR _7339_/Q sky130_fd_sc_hd__dfrtp_2
XFILLER_1_158 VGND VGND VPWR VPWR sky130_fd_sc_hd__decap_3
XPHY_EDGE_ROW_8_Left_125 VGND VGND VPWR VPWR sky130_fd_sc_hd__decap_3
XFILLER_1_169 VGND VGND VPWR VPWR sky130_fd_sc_hd__decap_3
XFILLER_38_21 VGND VGND VPWR VPWR sky130_fd_sc_hd__decap_3
XFILLER_77_438 VGND VGND VPWR VPWR sky130_fd_sc_hd__fill_1
XFILLER_38_54 VGND VGND VPWR VPWR sky130_fd_sc_hd__decap_3
XFILLER_77_449 VGND VGND VPWR VPWR sky130_fd_sc_hd__decap_3
XFILLER_58_663 VGND VGND VPWR VPWR sky130_fd_sc_hd__decap_3
XFILLER_73_611 VGND VGND VPWR VPWR sky130_fd_sc_hd__decap_3
Xhold1150 _7162_/Q VGND VGND VPWR VPWR _5338_/A0 sky130_fd_sc_hd__dlygate4sd3_1
XFILLER_18_527 VGND VGND VPWR VPWR sky130_fd_sc_hd__decap_3
XFILLER_73_644 VGND VGND VPWR VPWR sky130_fd_sc_hd__decap_3
Xhold1161 _7217_/Q VGND VGND VPWR VPWR _5223_/A sky130_fd_sc_hd__dlygate4sd3_1
Xhold1172 _7151_/Q VGND VGND VPWR VPWR _5360_/A0 sky130_fd_sc_hd__dlygate4sd3_1
Xhold1183 _7175_/Q VGND VGND VPWR VPWR _5310_/A0 sky130_fd_sc_hd__dlygate4sd3_1
Xhold1194 _7164_/Q VGND VGND VPWR VPWR _5333_/A0 sky130_fd_sc_hd__dlygate4sd3_1
XFILLER_54_42 VGND VGND VPWR VPWR sky130_fd_sc_hd__decap_3
XFILLER_72_165 VGND VGND VPWR VPWR sky130_fd_sc_hd__decap_3
XTAP_TAPCELL_ROW_28_588 VGND VPWR sky130_fd_sc_hd__tapvpwrvgnd_1
XFILLER_13_243 VGND VGND VPWR VPWR sky130_fd_sc_hd__decap_3
XFILLER_41_530 VGND VGND VPWR VPWR sky130_fd_sc_hd__decap_3
XFILLER_53_390 VGND VGND VPWR VPWR sky130_fd_sc_hd__fill_2
XFILLER_54_97 VGND VGND VPWR VPWR sky130_fd_sc_hd__decap_3
XFILLER_13_265 VGND VGND VPWR VPWR sky130_fd_sc_hd__decap_3
XFILLER_9_214 VGND VGND VPWR VPWR sky130_fd_sc_hd__decap_3
XFILLER_13_287 VGND VGND VPWR VPWR sky130_fd_sc_hd__decap_3
XFILLER_70_52 VGND VGND VPWR VPWR sky130_fd_sc_hd__decap_3
XFILLER_70_85 VGND VGND VPWR VPWR sky130_fd_sc_hd__decap_3
Xclkload17 _7386_/CLK VGND VGND VPWR VPWR clkload17/X sky130_fd_sc_hd__clkbuf_8
XFILLER_5_420 VGND VGND VPWR VPWR sky130_fd_sc_hd__decap_3
XFILLER_62_9 VGND VGND VPWR VPWR sky130_fd_sc_hd__decap_3
Xclkload28 _7005_/CLK VGND VGND VPWR VPWR clkload28/X sky130_fd_sc_hd__clkbuf_8
XFILLER_114_307 VGND VGND VPWR VPWR sky130_fd_sc_hd__fill_1
XFILLER_114_318 VGND VGND VPWR VPWR sky130_fd_sc_hd__decap_3
XFILLER_79_72 VGND VGND VPWR VPWR sky130_fd_sc_hd__decap_3
XFILLER_1_670 VGND VGND VPWR VPWR sky130_fd_sc_hd__fill_2
XFILLER_68_427 VGND VGND VPWR VPWR sky130_fd_sc_hd__decap_3
XFILLER_110_557 VGND VGND VPWR VPWR sky130_fd_sc_hd__decap_3
XFILLER_49_641 VGND VGND VPWR VPWR sky130_fd_sc_hd__decap_3
XFILLER_95_246 VGND VGND VPWR VPWR sky130_fd_sc_hd__decap_3
XFILLER_49_685 VGND VGND VPWR VPWR sky130_fd_sc_hd__decap_3
XFILLER_76_460 VGND VGND VPWR VPWR sky130_fd_sc_hd__decap_3
XFILLER_83_408 VGND VGND VPWR VPWR sky130_fd_sc_hd__decap_3
XFILLER_95_279 VGND VGND VPWR VPWR sky130_fd_sc_hd__fill_1
XFILLER_95_60 VGND VGND VPWR VPWR sky130_fd_sc_hd__decap_3
Xclkbuf_leaf_0_clk clkbuf_leaf_1_clk/A VGND VGND VPWR VPWR clkload7/A sky130_fd_sc_hd__clkbuf_16
XFILLER_36_335 VGND VGND VPWR VPWR sky130_fd_sc_hd__fill_2
XFILLER_48_195 VGND VGND VPWR VPWR sky130_fd_sc_hd__fill_1
XFILLER_64_622 VGND VGND VPWR VPWR sky130_fd_sc_hd__decap_3
XTAP_TAPCELL_ROW_47_820 VGND VPWR sky130_fd_sc_hd__tapvpwrvgnd_1
XFILLER_36_368 VGND VGND VPWR VPWR sky130_fd_sc_hd__fill_1
XFILLER_64_666 VGND VGND VPWR VPWR sky130_fd_sc_hd__decap_3
XFILLER_91_441 VGND VGND VPWR VPWR sky130_fd_sc_hd__decap_3
XFILLER_91_485 VGND VGND VPWR VPWR sky130_fd_sc_hd__decap_3
XFILLER_91_496 VGND VGND VPWR VPWR sky130_fd_sc_hd__decap_3
X_4971_ _4811_/C _4949_/Y _4967_/X _4969_/X _4970_/X VGND VGND VPWR VPWR _5661_/B
+ sky130_fd_sc_hd__a311oi_2
XFILLER_17_593 VGND VGND VPWR VPWR sky130_fd_sc_hd__decap_3
XFILLER_32_530 VGND VGND VPWR VPWR sky130_fd_sc_hd__fill_2
XFILLER_32_541 VGND VGND VPWR VPWR sky130_fd_sc_hd__fill_1
XFILLER_51_349 VGND VGND VPWR VPWR sky130_fd_sc_hd__decap_3
X_6710_ _6944_/CLK _6710_/D VGND VGND VPWR VPWR _6710_/Q sky130_fd_sc_hd__dfxtp_2
X_3922_ _6778_/Q _3926_/B1 _3925_/B1 _6866_/Q _3921_/X VGND VGND VPWR VPWR _3922_/X
+ sky130_fd_sc_hd__a221o_2
XTAP_TAPCELL_ROW_63_1011 VGND VPWR sky130_fd_sc_hd__tapvpwrvgnd_1
X_6641_ _6674_/A VGND VGND VPWR VPWR _6641_/Y sky130_fd_sc_hd__inv_2
X_3853_ _6736_/Q _3907_/A2 _3893_/B1 _6730_/Q _3852_/X VGND VGND VPWR VPWR _3853_/X
+ sky130_fd_sc_hd__a221o_2
X_6572_ _6604_/A VGND VGND VPWR VPWR _6572_/Y sky130_fd_sc_hd__inv_2
X_3784_ _6847_/Q _3661_/X _3892_/B1 _6842_/Q VGND VGND VPWR VPWR _3784_/X sky130_fd_sc_hd__a22o_2
XFILLER_8_280 VGND VGND VPWR VPWR sky130_fd_sc_hd__decap_3
Xoutput511 _5648_/A VGND VGND VPWR VPWR instruction_out[27] sky130_fd_sc_hd__clkdlybuf4s25_1
Xoutput500 _3392_/A VGND VGND VPWR VPWR instruction_out[15] sky130_fd_sc_hd__clkdlybuf4s25_1
Xoutput544 _5667_/A VGND VGND VPWR VPWR pc_out[2] sky130_fd_sc_hd__clkdlybuf4s25_1
Xoutput533 _7010_/Q VGND VGND VPWR VPWR pc_out[1] sky130_fd_sc_hd__clkdlybuf4s25_1
Xoutput522 _7009_/Q VGND VGND VPWR VPWR pc_out[0] sky130_fd_sc_hd__clkdlybuf4s25_1
X_4405_ _7242_/Q _4433_/B _3958_/S _7210_/Q VGND VGND VPWR VPWR _4405_/X sky130_fd_sc_hd__a22o_2
XFILLER_99_530 VGND VGND VPWR VPWR sky130_fd_sc_hd__decap_3
XFILLER_113_340 VGND VGND VPWR VPWR sky130_fd_sc_hd__decap_3
X_7124_ clkload5/A _7124_/D _6404_/Y VGND VGND VPWR VPWR _7124_/Q sky130_fd_sc_hd__dfrtp_2
X_4336_ _4336_/A _4336_/B _4336_/C VGND VGND VPWR VPWR _4336_/X sky130_fd_sc_hd__or3_2
XTAP_TAPCELL_ROW_74_1140 VGND VPWR sky130_fd_sc_hd__tapvpwrvgnd_1
XFILLER_101_502 VGND VGND VPWR VPWR sky130_fd_sc_hd__fill_2
XFILLER_115_26 VGND VGND VPWR VPWR sky130_fd_sc_hd__decap_3
XFILLER_59_449 VGND VGND VPWR VPWR sky130_fd_sc_hd__fill_2
X_7055_ clkload7/A _7055_/D _6335_/Y VGND VGND VPWR VPWR _7055_/Q sky130_fd_sc_hd__dfrtp_2
X_4267_ _7134_/Q _4351_/B1 _4352_/B1 _7166_/Q VGND VGND VPWR VPWR _4271_/B sky130_fd_sc_hd__a22o_2
XFILLER_27_302 VGND VGND VPWR VPWR sky130_fd_sc_hd__decap_3
XFILLER_39_151 VGND VGND VPWR VPWR sky130_fd_sc_hd__decap_3
XFILLER_55_600 VGND VGND VPWR VPWR sky130_fd_sc_hd__decap_3
X_4198_ _4194_/X _4197_/X _4327_/A VGND VGND VPWR VPWR _4380_/B sky130_fd_sc_hd__o21ai_2
XFILLER_54_121 VGND VGND VPWR VPWR sky130_fd_sc_hd__decap_3
XFILLER_55_644 VGND VGND VPWR VPWR sky130_fd_sc_hd__decap_3
XFILLER_67_493 VGND VGND VPWR VPWR sky130_fd_sc_hd__decap_3
XFILLER_54_132 VGND VGND VPWR VPWR sky130_fd_sc_hd__decap_3
XFILLER_82_452 VGND VGND VPWR VPWR sky130_fd_sc_hd__fill_2
XFILLER_54_165 VGND VGND VPWR VPWR sky130_fd_sc_hd__decap_3
XFILLER_55_688 VGND VGND VPWR VPWR sky130_fd_sc_hd__decap_3
XFILLER_70_625 VGND VGND VPWR VPWR sky130_fd_sc_hd__decap_3
XFILLER_91_18 VGND VGND VPWR VPWR sky130_fd_sc_hd__decap_3
XFILLER_24_23 VGND VGND VPWR VPWR sky130_fd_sc_hd__decap_3
XFILLER_70_669 VGND VGND VPWR VPWR sky130_fd_sc_hd__decap_3
X_6908_ _6944_/CLK _6908_/D VGND VGND VPWR VPWR _6908_/Q sky130_fd_sc_hd__dfxtp_2
XTAP_TAPCELL_ROW_25_547 VGND VPWR sky130_fd_sc_hd__tapvpwrvgnd_1
XFILLER_24_45 VGND VGND VPWR VPWR sky130_fd_sc_hd__decap_3
XFILLER_50_360 VGND VGND VPWR VPWR sky130_fd_sc_hd__fill_1
X_6839_ _6946_/CLK _6839_/D VGND VGND VPWR VPWR _6839_/Q sky130_fd_sc_hd__dfxtp_2
XTAP_TAPCELL_ROW_53_889 VGND VPWR sky130_fd_sc_hd__tapvpwrvgnd_1
XFILLER_10_224 VGND VGND VPWR VPWR sky130_fd_sc_hd__decap_3
XFILLER_10_268 VGND VGND VPWR VPWR sky130_fd_sc_hd__decap_3
XFILLER_6_206 VGND VGND VPWR VPWR sky130_fd_sc_hd__fill_2
XFILLER_108_112 VGND VGND VPWR VPWR sky130_fd_sc_hd__decap_3
XFILLER_109_635 VGND VGND VPWR VPWR sky130_fd_sc_hd__decap_3
XFILLER_6_228 VGND VGND VPWR VPWR sky130_fd_sc_hd__decap_3
XFILLER_108_156 VGND VGND VPWR VPWR sky130_fd_sc_hd__decap_3
XFILLER_109_668 VGND VGND VPWR VPWR sky130_fd_sc_hd__decap_3
XFILLER_109_679 VGND VGND VPWR VPWR sky130_fd_sc_hd__decap_3
XFILLER_40_66 VGND VGND VPWR VPWR sky130_fd_sc_hd__decap_3
XFILLER_108_189 VGND VGND VPWR VPWR sky130_fd_sc_hd__decap_3
XFILLER_2_401 VGND VGND VPWR VPWR sky130_fd_sc_hd__decap_3
XFILLER_40_99 VGND VGND VPWR VPWR sky130_fd_sc_hd__decap_3
XFILLER_2_445 VGND VGND VPWR VPWR sky130_fd_sc_hd__decap_3
XFILLER_6_3 VGND VGND VPWR VPWR sky130_fd_sc_hd__decap_3
XFILLER_49_42 VGND VGND VPWR VPWR sky130_fd_sc_hd__decap_3
XFILLER_104_395 VGND VGND VPWR VPWR sky130_fd_sc_hd__decap_3
XFILLER_49_75 VGND VGND VPWR VPWR sky130_fd_sc_hd__decap_3
XFILLER_77_235 VGND VGND VPWR VPWR sky130_fd_sc_hd__fill_2
XFILLER_1_38 VGND VGND VPWR VPWR sky130_fd_sc_hd__decap_3
XFILLER_65_408 VGND VGND VPWR VPWR sky130_fd_sc_hd__decap_3
XFILLER_77_257 VGND VGND VPWR VPWR sky130_fd_sc_hd__decap_3
XTAP_TAPCELL_ROW_88_1309 VGND VPWR sky130_fd_sc_hd__tapvpwrvgnd_1
XFILLER_105_81 VGND VGND VPWR VPWR sky130_fd_sc_hd__decap_3
XFILLER_105_92 VGND VGND VPWR VPWR sky130_fd_sc_hd__decap_3
XFILLER_18_368 VGND VGND VPWR VPWR sky130_fd_sc_hd__decap_3
XFILLER_46_666 VGND VGND VPWR VPWR sky130_fd_sc_hd__decap_3
XFILLER_65_63 VGND VGND VPWR VPWR sky130_fd_sc_hd__decap_3
XFILLER_73_441 VGND VGND VPWR VPWR sky130_fd_sc_hd__decap_3
XFILLER_18_379 VGND VGND VPWR VPWR sky130_fd_sc_hd__decap_3
XFILLER_45_187 VGND VGND VPWR VPWR sky130_fd_sc_hd__fill_2
XFILLER_61_614 VGND VGND VPWR VPWR sky130_fd_sc_hd__fill_2
XFILLER_65_96 VGND VGND VPWR VPWR sky130_fd_sc_hd__decap_3
XFILLER_14_541 VGND VGND VPWR VPWR sky130_fd_sc_hd__decap_3
XFILLER_33_349 VGND VGND VPWR VPWR sky130_fd_sc_hd__fill_1
XFILLER_60_135 VGND VGND VPWR VPWR sky130_fd_sc_hd__decap_3
XFILLER_61_647 VGND VGND VPWR VPWR sky130_fd_sc_hd__decap_3
XFILLER_60_168 VGND VGND VPWR VPWR sky130_fd_sc_hd__decap_3
XFILLER_81_51 VGND VGND VPWR VPWR sky130_fd_sc_hd__decap_3
XFILLER_41_393 VGND VGND VPWR VPWR sky130_fd_sc_hd__fill_1
XFILLER_81_95 VGND VGND VPWR VPWR sky130_fd_sc_hd__decap_3
XTAP_TAPCELL_ROW_99_1438 VGND VPWR sky130_fd_sc_hd__tapvpwrvgnd_1
XFILLER_60_6 VGND VGND VPWR VPWR sky130_fd_sc_hd__decap_3
XFILLER_114_115 VGND VGND VPWR VPWR sky130_fd_sc_hd__decap_3
XFILLER_115_638 VGND VGND VPWR VPWR sky130_fd_sc_hd__decap_3
XFILLER_114_159 VGND VGND VPWR VPWR sky130_fd_sc_hd__decap_3
XFILLER_39_3 VGND VGND VPWR VPWR sky130_fd_sc_hd__decap_3
XFILLER_96_500 VGND VGND VPWR VPWR sky130_fd_sc_hd__decap_3
X_4121_ _7140_/Q _4195_/A2 _4352_/B1 _7172_/Q _4120_/X VGND VGND VPWR VPWR _4121_/X
+ sky130_fd_sc_hd__a221o_2
XFILLER_110_365 VGND VGND VPWR VPWR sky130_fd_sc_hd__decap_3
XFILLER_56_408 VGND VGND VPWR VPWR sky130_fd_sc_hd__decap_3
X_4052_ _4047_/X _4050_/X _4425_/A VGND VGND VPWR VPWR _4456_/A sky130_fd_sc_hd__o21a_2
XFILLER_83_238 VGND VGND VPWR VPWR sky130_fd_sc_hd__decap_3
XTAP_TAPCELL_ROW_108_1545 VGND VPWR sky130_fd_sc_hd__tapvpwrvgnd_1
XFILLER_37_688 VGND VGND VPWR VPWR sky130_fd_sc_hd__decap_3
XFILLER_51_102 VGND VGND VPWR VPWR sky130_fd_sc_hd__fill_2
XFILLER_52_625 VGND VGND VPWR VPWR sky130_fd_sc_hd__decap_3
XFILLER_91_271 VGND VGND VPWR VPWR sky130_fd_sc_hd__decap_3
XFILLER_101_17 VGND VGND VPWR VPWR sky130_fd_sc_hd__decap_3
XFILLER_52_669 VGND VGND VPWR VPWR sky130_fd_sc_hd__decap_3
X_4954_ _4634_/D _4969_/C _4953_/Y _4200_/X VGND VGND VPWR VPWR _4954_/X sky130_fd_sc_hd__o211a_2
X_3905_ hold966/X _5104_/A _3904_/Y VGND VGND VPWR VPWR _7380_/D sky130_fd_sc_hd__a21bo_2
X_4885_ _4904_/B _4903_/A VGND VGND VPWR VPWR _4886_/C sky130_fd_sc_hd__and2b_2
XTAP_TAPCELL_ROW_50_848 VGND VPWR sky130_fd_sc_hd__tapvpwrvgnd_1
XTAP_TAPCELL_ROW_22_517 VGND VPWR sky130_fd_sc_hd__tapvpwrvgnd_1
XFILLER_20_544 VGND VGND VPWR VPWR sky130_fd_sc_hd__decap_3
X_6624_ _6660_/A VGND VGND VPWR VPWR _6624_/Y sky130_fd_sc_hd__inv_2
X_3836_ _6970_/Q _3656_/Y _3665_/X _6720_/Q _3835_/X VGND VGND VPWR VPWR _3836_/X
+ sky130_fd_sc_hd__a221o_2
X_6555_ _6647_/A VGND VGND VPWR VPWR _6555_/Y sky130_fd_sc_hd__inv_2
X_3767_ _6705_/Q _3767_/A2 _3767_/B1 _6883_/Q VGND VGND VPWR VPWR _3767_/X sky130_fd_sc_hd__a22o_2
XPHY_EDGE_ROW_89_Left_206 VGND VGND VPWR VPWR sky130_fd_sc_hd__decap_3
XFILLER_106_627 VGND VGND VPWR VPWR sky130_fd_sc_hd__decap_3
X_6486_ _6684_/A VGND VGND VPWR VPWR _6486_/Y sky130_fd_sc_hd__inv_2
X_3698_ hold995/X _3757_/S _3697_/Y VGND VGND VPWR VPWR _7402_/D sky130_fd_sc_hd__o21ba_2
XFILLER_10_47 VGND VGND VPWR VPWR sky130_fd_sc_hd__decap_3
XFILLER_114_660 VGND VGND VPWR VPWR sky130_fd_sc_hd__decap_3
XFILLER_87_522 VGND VGND VPWR VPWR sky130_fd_sc_hd__fill_1
XFILLER_113_181 VGND VGND VPWR VPWR sky130_fd_sc_hd__decap_3
XFILLER_87_544 VGND VGND VPWR VPWR sky130_fd_sc_hd__fill_2
XFILLER_87_555 VGND VGND VPWR VPWR sky130_fd_sc_hd__fill_1
X_7107_ _7234_/CLK _7107_/D _6387_/Y VGND VGND VPWR VPWR _7107_/Q sky130_fd_sc_hd__dfrtp_2
X_4319_ _7258_/Q _4341_/A2 _4316_/X _4318_/X VGND VGND VPWR VPWR _4362_/A sky130_fd_sc_hd__a211o_2
XFILLER_99_393 VGND VGND VPWR VPWR sky130_fd_sc_hd__decap_3
XFILLER_101_343 VGND VGND VPWR VPWR sky130_fd_sc_hd__decap_3
XFILLER_19_23 VGND VGND VPWR VPWR sky130_fd_sc_hd__decap_3
XFILLER_47_408 VGND VGND VPWR VPWR sky130_fd_sc_hd__decap_3
XFILLER_59_268 VGND VGND VPWR VPWR sky130_fd_sc_hd__decap_3
X_7038_ _7390_/CLK _7038_/D _6318_/Y VGND VGND VPWR VPWR _7038_/Q sky130_fd_sc_hd__dfrtp_2
XPHY_EDGE_ROW_98_Left_215 VGND VGND VPWR VPWR sky130_fd_sc_hd__decap_3
XFILLER_19_89 VGND VGND VPWR VPWR sky130_fd_sc_hd__decap_3
XFILLER_28_611 VGND VGND VPWR VPWR sky130_fd_sc_hd__decap_3
XTAP_TAPCELL_ROW_58_948 VGND VPWR sky130_fd_sc_hd__tapvpwrvgnd_1
XFILLER_27_143 VGND VGND VPWR VPWR sky130_fd_sc_hd__decap_3
XFILLER_15_305 VGND VGND VPWR VPWR sky130_fd_sc_hd__fill_1
XFILLER_35_11 VGND VGND VPWR VPWR sky130_fd_sc_hd__decap_3
XFILLER_43_614 VGND VGND VPWR VPWR sky130_fd_sc_hd__fill_2
XFILLER_55_474 VGND VGND VPWR VPWR sky130_fd_sc_hd__fill_2
XTAP_TAPCELL_ROW_2_275 VGND VPWR sky130_fd_sc_hd__tapvpwrvgnd_1
XFILLER_27_198 VGND VGND VPWR VPWR sky130_fd_sc_hd__decap_3
XFILLER_43_669 VGND VGND VPWR VPWR sky130_fd_sc_hd__decap_3
XFILLER_70_433 VGND VGND VPWR VPWR sky130_fd_sc_hd__decap_3
XFILLER_70_477 VGND VGND VPWR VPWR sky130_fd_sc_hd__decap_3
XFILLER_11_533 VGND VGND VPWR VPWR sky130_fd_sc_hd__fill_1
XFILLER_51_21 VGND VGND VPWR VPWR sky130_fd_sc_hd__fill_2
XFILLER_51_691 VGND VGND VPWR VPWR sky130_fd_sc_hd__fill_1
XFILLER_109_432 VGND VGND VPWR VPWR sky130_fd_sc_hd__fill_2
XFILLER_11_588 VGND VGND VPWR VPWR sky130_fd_sc_hd__decap_3
XFILLER_109_498 VGND VGND VPWR VPWR sky130_fd_sc_hd__decap_3
XTAP_TAPCELL_ROW_94_1379 VGND VPWR sky130_fd_sc_hd__tapvpwrvgnd_1
XFILLER_105_671 VGND VGND VPWR VPWR sky130_fd_sc_hd__fill_1
XFILLER_105_682 VGND VGND VPWR VPWR sky130_fd_sc_hd__decap_3
XFILLER_112_619 VGND VGND VPWR VPWR sky130_fd_sc_hd__decap_3
XFILLER_2_264 VGND VGND VPWR VPWR sky130_fd_sc_hd__decap_3
XFILLER_97_308 VGND VGND VPWR VPWR sky130_fd_sc_hd__decap_3
XFILLER_116_80 VGND VGND VPWR VPWR sky130_fd_sc_hd__decap_3
XFILLER_25_9 VGND VGND VPWR VPWR sky130_fd_sc_hd__decap_3
XFILLER_93_514 VGND VGND VPWR VPWR sky130_fd_sc_hd__decap_3
XFILLER_76_62 VGND VGND VPWR VPWR sky130_fd_sc_hd__decap_3
XFILLER_18_110 VGND VGND VPWR VPWR sky130_fd_sc_hd__fill_2
XFILLER_46_430 VGND VGND VPWR VPWR sky130_fd_sc_hd__decap_3
XFILLER_58_290 VGND VGND VPWR VPWR sky130_fd_sc_hd__decap_3
XFILLER_73_260 VGND VGND VPWR VPWR sky130_fd_sc_hd__decap_3
XFILLER_33_113 VGND VGND VPWR VPWR sky130_fd_sc_hd__decap_3
XFILLER_21_308 VGND VGND VPWR VPWR sky130_fd_sc_hd__decap_3
XFILLER_33_146 VGND VGND VPWR VPWR sky130_fd_sc_hd__decap_3
XFILLER_14_371 VGND VGND VPWR VPWR sky130_fd_sc_hd__decap_3
XFILLER_42_680 VGND VGND VPWR VPWR sky130_fd_sc_hd__decap_3
XTAP_TAPCELL_ROW_103_1486 VGND VPWR sky130_fd_sc_hd__tapvpwrvgnd_1
X_4670_ _6995_/Q _5633_/B VGND VGND VPWR VPWR _4682_/B sky130_fd_sc_hd__or2_2
X_3621_ _3621_/A _3621_/B VGND VGND VPWR VPWR _4852_/A sky130_fd_sc_hd__nand2_2
X_6340_ _6347_/A VGND VGND VPWR VPWR _6340_/Y sky130_fd_sc_hd__inv_2
X_3552_ _3508_/Y _5020_/A _3620_/A _3537_/X _3551_/X VGND VGND VPWR VPWR _3746_/A
+ sky130_fd_sc_hd__o311a_2
X_6271_ _6553_/A VGND VGND VPWR VPWR _6271_/Y sky130_fd_sc_hd__inv_2
X_3483_ _3442_/A _3442_/B _3409_/D VGND VGND VPWR VPWR _5153_/B sky130_fd_sc_hd__a21o_2
XFILLER_102_107 VGND VGND VPWR VPWR sky130_fd_sc_hd__decap_3
X_5153_ _7010_/D _5153_/B VGND VGND VPWR VPWR _5153_/X sky130_fd_sc_hd__xor2_2
XFILLER_111_641 VGND VGND VPWR VPWR sky130_fd_sc_hd__decap_3
XFILLER_29_408 VGND VGND VPWR VPWR sky130_fd_sc_hd__decap_3
XFILLER_69_588 VGND VGND VPWR VPWR sky130_fd_sc_hd__decap_3
X_4104_ _7237_/Q _4433_/B _4493_/S _7050_/Q VGND VGND VPWR VPWR _4104_/X sky130_fd_sc_hd__a22o_2
XFILLER_110_162 VGND VGND VPWR VPWR sky130_fd_sc_hd__decap_3
XFILLER_111_685 VGND VGND VPWR VPWR sky130_fd_sc_hd__decap_3
XFILLER_56_227 VGND VGND VPWR VPWR sky130_fd_sc_hd__decap_3
XFILLER_84_536 VGND VGND VPWR VPWR sky130_fd_sc_hd__fill_2
XFILLER_96_396 VGND VGND VPWR VPWR sky130_fd_sc_hd__decap_3
X_5084_ _4343_/X _5084_/B _5086_/A VGND VGND VPWR VPWR _5084_/X sky130_fd_sc_hd__and3b_2
XFILLER_110_195 VGND VGND VPWR VPWR sky130_fd_sc_hd__fill_1
XFILLER_84_558 VGND VGND VPWR VPWR sky130_fd_sc_hd__fill_1
X_4035_ _7374_/Q _4435_/B1 _4436_/B1 _7182_/Q _4034_/X VGND VGND VPWR VPWR _4035_/X
+ sky130_fd_sc_hd__a221o_2
XTAP_TAPCELL_ROW_55_907 VGND VPWR sky130_fd_sc_hd__tapvpwrvgnd_1
XFILLER_112_38 VGND VGND VPWR VPWR sky130_fd_sc_hd__decap_3
XFILLER_24_124 VGND VGND VPWR VPWR sky130_fd_sc_hd__fill_1
XFILLER_24_135 VGND VGND VPWR VPWR sky130_fd_sc_hd__decap_3
XFILLER_25_647 VGND VGND VPWR VPWR sky130_fd_sc_hd__fill_1
XFILLER_52_433 VGND VGND VPWR VPWR sky130_fd_sc_hd__decap_3
XTAP_TAPCELL_ROW_69_1083 VGND VPWR sky130_fd_sc_hd__tapvpwrvgnd_1
XFILLER_25_669 VGND VGND VPWR VPWR sky130_fd_sc_hd__decap_3
XFILLER_40_606 VGND VGND VPWR VPWR sky130_fd_sc_hd__decap_3
XFILLER_52_477 VGND VGND VPWR VPWR sky130_fd_sc_hd__fill_2
X_4937_ _4937_/A _4937_/B VGND VGND VPWR VPWR _4937_/Y sky130_fd_sc_hd__xnor2_2
XTAP_TAPCELL_ROW_35_675 VGND VPWR sky130_fd_sc_hd__tapvpwrvgnd_1
X_4868_ _6999_/Q _4882_/A VGND VGND VPWR VPWR _6999_/D sky130_fd_sc_hd__xnor2_2
X_6607_ _6608_/A VGND VGND VPWR VPWR _6607_/Y sky130_fd_sc_hd__inv_2
X_3819_ _6791_/Q _3862_/B1 _3925_/B1 _6879_/Q VGND VGND VPWR VPWR _3819_/X sky130_fd_sc_hd__a22o_2
XFILLER_21_24 VGND VGND VPWR VPWR sky130_fd_sc_hd__fill_1
X_4799_ _4799_/A _5656_/A VGND VGND VPWR VPWR _4799_/X sky130_fd_sc_hd__or2_2
XFILLER_106_424 VGND VGND VPWR VPWR sky130_fd_sc_hd__decap_3
XFILLER_21_57 VGND VGND VPWR VPWR sky130_fd_sc_hd__decap_3
XFILLER_21_79 VGND VGND VPWR VPWR sky130_fd_sc_hd__decap_3
X_6538_ _6539_/A VGND VGND VPWR VPWR _6538_/Y sky130_fd_sc_hd__inv_2
XFILLER_106_457 VGND VGND VPWR VPWR sky130_fd_sc_hd__decap_3
XFILLER_108_6 VGND VGND VPWR VPWR sky130_fd_sc_hd__decap_3
X_6469_ _6535_/A VGND VGND VPWR VPWR _6469_/Y sky130_fd_sc_hd__inv_2
XFILLER_102_630 VGND VGND VPWR VPWR sky130_fd_sc_hd__decap_3
XTAP_TAPCELL_ROW_7_334 VGND VPWR sky130_fd_sc_hd__tapvpwrvgnd_1
XFILLER_102_663 VGND VGND VPWR VPWR sky130_fd_sc_hd__decap_3
XPHY_EDGE_ROW_102_Right_102 VGND VGND VPWR VPWR sky130_fd_sc_hd__decap_3
XFILLER_101_162 VGND VGND VPWR VPWR sky130_fd_sc_hd__decap_3
XFILLER_47_205 VGND VGND VPWR VPWR sky130_fd_sc_hd__decap_3
XFILLER_75_514 VGND VGND VPWR VPWR sky130_fd_sc_hd__fill_1
XFILLER_28_430 VGND VGND VPWR VPWR sky130_fd_sc_hd__decap_3
XFILLER_28_441 VGND VGND VPWR VPWR sky130_fd_sc_hd__decap_3
XFILLER_75_547 VGND VGND VPWR VPWR sky130_fd_sc_hd__decap_3
XFILLER_43_400 VGND VGND VPWR VPWR sky130_fd_sc_hd__decap_3
XFILLER_55_260 VGND VGND VPWR VPWR sky130_fd_sc_hd__decap_3
XFILLER_62_208 VGND VGND VPWR VPWR sky130_fd_sc_hd__decap_3
XFILLER_90_539 VGND VGND VPWR VPWR sky130_fd_sc_hd__decap_3
XFILLER_15_124 VGND VGND VPWR VPWR sky130_fd_sc_hd__decap_3
XFILLER_43_433 VGND VGND VPWR VPWR sky130_fd_sc_hd__decap_3
XFILLER_31_617 VGND VGND VPWR VPWR sky130_fd_sc_hd__decap_3
XFILLER_43_455 VGND VGND VPWR VPWR sky130_fd_sc_hd__decap_3
XFILLER_24_691 VGND VGND VPWR VPWR sky130_fd_sc_hd__fill_1
XFILLER_62_42 VGND VGND VPWR VPWR sky130_fd_sc_hd__decap_3
XFILLER_70_274 VGND VGND VPWR VPWR sky130_fd_sc_hd__decap_3
XFILLER_23_190 VGND VGND VPWR VPWR sky130_fd_sc_hd__decap_3
XFILLER_11_363 VGND VGND VPWR VPWR sky130_fd_sc_hd__decap_3
XFILLER_7_15 VGND VGND VPWR VPWR sky130_fd_sc_hd__decap_3
XTAP_TAPCELL_ROW_96_1408 VGND VPWR sky130_fd_sc_hd__tapvpwrvgnd_1
XFILLER_11_396 VGND VGND VPWR VPWR sky130_fd_sc_hd__fill_2
XFILLER_7_48 VGND VGND VPWR VPWR sky130_fd_sc_hd__decap_3
XFILLER_109_262 VGND VGND VPWR VPWR sky130_fd_sc_hd__fill_2
XFILLER_7_367 VGND VGND VPWR VPWR sky130_fd_sc_hd__decap_3
XFILLER_11_90 VGND VGND VPWR VPWR sky130_fd_sc_hd__decap_3
XFILLER_98_639 VGND VGND VPWR VPWR sky130_fd_sc_hd__decap_3
XFILLER_105_490 VGND VGND VPWR VPWR sky130_fd_sc_hd__decap_3
XFILLER_112_427 VGND VGND VPWR VPWR sky130_fd_sc_hd__fill_1
XFILLER_3_584 VGND VGND VPWR VPWR sky130_fd_sc_hd__decap_3
XFILLER_87_50 VGND VGND VPWR VPWR sky130_fd_sc_hd__decap_3
XFILLER_23_6 VGND VGND VPWR VPWR sky130_fd_sc_hd__decap_3
XFILLER_66_503 VGND VGND VPWR VPWR sky130_fd_sc_hd__decap_3
XFILLER_78_330 VGND VGND VPWR VPWR sky130_fd_sc_hd__decap_3
XFILLER_87_72 VGND VGND VPWR VPWR sky130_fd_sc_hd__fill_2
XFILLER_93_333 VGND VGND VPWR VPWR sky130_fd_sc_hd__decap_3
XFILLER_93_344 VGND VGND VPWR VPWR sky130_fd_sc_hd__decap_3
XTAP_TAPCELL_ROW_105_1515 VGND VPWR sky130_fd_sc_hd__tapvpwrvgnd_1
XFILLER_61_252 VGND VGND VPWR VPWR sky130_fd_sc_hd__decap_3
XFILLER_21_116 VGND VGND VPWR VPWR sky130_fd_sc_hd__decap_3
XTAP_TAPCELL_ROW_32_634 VGND VPWR sky130_fd_sc_hd__tapvpwrvgnd_1
XTAP_TAPCELL_ROW_60_976 VGND VPWR sky130_fd_sc_hd__tapvpwrvgnd_1
X_4653_ _4648_/Y _4785_/A _4413_/A _4397_/A VGND VGND VPWR VPWR _4653_/Y sky130_fd_sc_hd__a211oi_2
X_7372_ _7372_/CLK _7372_/D _6652_/Y VGND VGND VPWR VPWR _7372_/Q sky130_fd_sc_hd__dfrtp_2
Xhold802 _6850_/Q VGND VGND VPWR VPWR _6850_/D sky130_fd_sc_hd__dlygate4sd3_1
X_3604_ _4938_/A _5072_/A VGND VGND VPWR VPWR _3621_/B sky130_fd_sc_hd__nor2_2
XTAP_TAPCELL_ROW_12_391 VGND VPWR sky130_fd_sc_hd__tapvpwrvgnd_1
Xhold813 _6827_/Q VGND VGND VPWR VPWR _6827_/D sky130_fd_sc_hd__dlygate4sd3_1
Xhold824 _6822_/Q VGND VGND VPWR VPWR _6822_/D sky130_fd_sc_hd__dlygate4sd3_1
Xhold835 _6909_/Q VGND VGND VPWR VPWR _6909_/D sky130_fd_sc_hd__dlygate4sd3_1
Xhold846 _7058_/Q VGND VGND VPWR VPWR _7058_/D sky130_fd_sc_hd__dlygate4sd3_1
X_6323_ _6674_/A VGND VGND VPWR VPWR _6323_/Y sky130_fd_sc_hd__inv_2
X_3535_ _3621_/A _5071_/A _4764_/B VGND VGND VPWR VPWR _3536_/B sky130_fd_sc_hd__and3_2
XTAP_TAPCELL_ROW_116_1655 VGND VPWR sky130_fd_sc_hd__tapvpwrvgnd_1
XTAP_TAPCELL_ROW_116_1644 VGND VPWR sky130_fd_sc_hd__tapvpwrvgnd_1
XFILLER_107_38 VGND VGND VPWR VPWR sky130_fd_sc_hd__decap_3
XFILLER_115_243 VGND VGND VPWR VPWR sky130_fd_sc_hd__decap_3
XFILLER_115_276 VGND VGND VPWR VPWR sky130_fd_sc_hd__decap_3
XFILLER_88_105 VGND VGND VPWR VPWR sky130_fd_sc_hd__decap_3
XFILLER_89_617 VGND VGND VPWR VPWR sky130_fd_sc_hd__decap_3
Xhold857 _7109_/Q VGND VGND VPWR VPWR _7109_/D sky130_fd_sc_hd__dlygate4sd3_1
Xhold868 _7087_/Q VGND VGND VPWR VPWR _7087_/D sky130_fd_sc_hd__dlygate4sd3_1
Xhold879 _7059_/Q VGND VGND VPWR VPWR _7059_/D sky130_fd_sc_hd__dlygate4sd3_1
Xmax_cap576 fanout39/X VGND VGND VPWR VPWR _6536_/A sky130_fd_sc_hd__buf_2
Xmax_cap565 _4282_/Y VGND VGND VPWR VPWR _4612_/A sky130_fd_sc_hd__buf_2
X_3466_ _7217_/Q _4331_/A2 _4534_/S _7030_/Q _3465_/X VGND VGND VPWR VPWR _3466_/X
+ sky130_fd_sc_hd__a221o_2
XFILLER_103_438 VGND VGND VPWR VPWR sky130_fd_sc_hd__decap_3
XFILLER_103_449 VGND VGND VPWR VPWR sky130_fd_sc_hd__decap_3
XFILLER_115_287 VGND VGND VPWR VPWR sky130_fd_sc_hd__decap_3
XFILLER_88_138 VGND VGND VPWR VPWR sky130_fd_sc_hd__fill_2
XFILLER_88_149 VGND VGND VPWR VPWR sky130_fd_sc_hd__decap_3
X_5205_ _5205_/A _5205_/B VGND VGND VPWR VPWR _7226_/D sky130_fd_sc_hd__and2_2
XTAP_TAPCELL_ROW_4_304 VGND VPWR sky130_fd_sc_hd__tapvpwrvgnd_1
XFILLER_97_650 VGND VGND VPWR VPWR sky130_fd_sc_hd__decap_3
XFILLER_84_322 VGND VGND VPWR VPWR sky130_fd_sc_hd__decap_3
X_5136_ _5136_/A0 _5135_/X _5136_/S VGND VGND VPWR VPWR _7251_/D sky130_fd_sc_hd__mux2_2
XFILLER_96_193 VGND VGND VPWR VPWR sky130_fd_sc_hd__decap_3
X_5067_ _5648_/A _5067_/B VGND VGND VPWR VPWR _5068_/C sky130_fd_sc_hd__or2_2
XFILLER_37_260 VGND VGND VPWR VPWR sky130_fd_sc_hd__decap_3
XFILLER_44_219 VGND VGND VPWR VPWR sky130_fd_sc_hd__fill_2
XFILLER_84_377 VGND VGND VPWR VPWR sky130_fd_sc_hd__fill_1
X_4018_ _7150_/Q _5229_/C _4011_/X _4017_/X VGND VGND VPWR VPWR _4018_/X sky130_fd_sc_hd__a211o_2
XFILLER_16_24 VGND VGND VPWR VPWR sky130_fd_sc_hd__decap_3
XFILLER_16_35 VGND VGND VPWR VPWR sky130_fd_sc_hd__decap_3
XFILLER_25_411 VGND VGND VPWR VPWR sky130_fd_sc_hd__decap_3
XFILLER_65_591 VGND VGND VPWR VPWR sky130_fd_sc_hd__decap_3
XFILLER_16_68 VGND VGND VPWR VPWR sky130_fd_sc_hd__decap_3
XFILLER_80_550 VGND VGND VPWR VPWR sky130_fd_sc_hd__decap_3
XTAP_TAPCELL_ROW_80_1209 VGND VPWR sky130_fd_sc_hd__tapvpwrvgnd_1
XFILLER_12_116 VGND VGND VPWR VPWR sky130_fd_sc_hd__decap_3
XFILLER_12_138 VGND VGND VPWR VPWR sky130_fd_sc_hd__fill_2
XFILLER_8_109 VGND VGND VPWR VPWR sky130_fd_sc_hd__decap_3
XFILLER_20_193 VGND VGND VPWR VPWR sky130_fd_sc_hd__decap_3
XFILLER_32_67 VGND VGND VPWR VPWR sky130_fd_sc_hd__fill_1
XFILLER_106_3 VGND VGND VPWR VPWR sky130_fd_sc_hd__decap_3
XFILLER_106_265 VGND VGND VPWR VPWR sky130_fd_sc_hd__decap_3
XTAP_TAPCELL_ROW_91_1338 VGND VPWR sky130_fd_sc_hd__tapvpwrvgnd_1
XFILLER_79_116 VGND VGND VPWR VPWR sky130_fd_sc_hd__decap_3
XTAP_TAPCELL_ROW_91_1349 VGND VPWR sky130_fd_sc_hd__tapvpwrvgnd_1
XFILLER_102_460 VGND VGND VPWR VPWR sky130_fd_sc_hd__decap_3
XFILLER_48_536 VGND VGND VPWR VPWR sky130_fd_sc_hd__fill_2
XFILLER_57_20 VGND VGND VPWR VPWR sky130_fd_sc_hd__decap_3
XFILLER_88_672 VGND VGND VPWR VPWR sky130_fd_sc_hd__decap_3
XFILLER_48_547 VGND VGND VPWR VPWR sky130_fd_sc_hd__decap_3
XFILLER_57_86 VGND VGND VPWR VPWR sky130_fd_sc_hd__fill_1
XFILLER_75_355 VGND VGND VPWR VPWR sky130_fd_sc_hd__fill_2
XFILLER_57_97 VGND VGND VPWR VPWR sky130_fd_sc_hd__decap_3
XFILLER_113_81 VGND VGND VPWR VPWR sky130_fd_sc_hd__decap_3
XFILLER_16_411 VGND VGND VPWR VPWR sky130_fd_sc_hd__fill_1
XFILLER_28_271 VGND VGND VPWR VPWR sky130_fd_sc_hd__decap_3
XFILLER_63_539 VGND VGND VPWR VPWR sky130_fd_sc_hd__fill_2
XFILLER_75_399 VGND VGND VPWR VPWR sky130_fd_sc_hd__decap_3
XFILLER_16_444 VGND VGND VPWR VPWR sky130_fd_sc_hd__decap_3
XFILLER_71_561 VGND VGND VPWR VPWR sky130_fd_sc_hd__fill_1
XFILLER_73_52 VGND VGND VPWR VPWR sky130_fd_sc_hd__decap_3
XFILLER_73_96 VGND VGND VPWR VPWR sky130_fd_sc_hd__fill_2
XFILLER_31_447 VGND VGND VPWR VPWR sky130_fd_sc_hd__fill_1
XFILLER_31_458 VGND VGND VPWR VPWR sky130_fd_sc_hd__decap_3
XFILLER_43_296 VGND VGND VPWR VPWR sky130_fd_sc_hd__decap_3
XFILLER_92_9 VGND VGND VPWR VPWR sky130_fd_sc_hd__decap_3
XFILLER_8_610 VGND VGND VPWR VPWR sky130_fd_sc_hd__fill_1
XTAP_TAPCELL_ROW_100_1456 VGND VPWR sky130_fd_sc_hd__tapvpwrvgnd_1
XFILLER_11_182 VGND VGND VPWR VPWR sky130_fd_sc_hd__decap_3
XFILLER_12_683 VGND VGND VPWR VPWR sky130_fd_sc_hd__fill_1
XFILLER_7_131 VGND VGND VPWR VPWR sky130_fd_sc_hd__decap_3
XFILLER_8_665 VGND VGND VPWR VPWR sky130_fd_sc_hd__decap_3
XFILLER_7_164 VGND VGND VPWR VPWR sky130_fd_sc_hd__fill_1
X_3320_ _5647_/B VGND VGND VPWR VPWR _3326_/A sky130_fd_sc_hd__inv_2
XFILLER_98_71 VGND VGND VPWR VPWR sky130_fd_sc_hd__decap_3
XFILLER_98_403 VGND VGND VPWR VPWR sky130_fd_sc_hd__decap_3
XFILLER_112_224 VGND VGND VPWR VPWR sky130_fd_sc_hd__decap_3
XFILLER_3_381 VGND VGND VPWR VPWR sky130_fd_sc_hd__decap_3
XFILLER_98_447 VGND VGND VPWR VPWR sky130_fd_sc_hd__decap_3
XFILLER_112_257 VGND VGND VPWR VPWR sky130_fd_sc_hd__fill_1
XFILLER_79_650 VGND VGND VPWR VPWR sky130_fd_sc_hd__decap_3
XFILLER_86_609 VGND VGND VPWR VPWR sky130_fd_sc_hd__decap_3
XFILLER_21_3 VGND VGND VPWR VPWR sky130_fd_sc_hd__decap_3
XFILLER_85_119 VGND VGND VPWR VPWR sky130_fd_sc_hd__decap_3
XTAP_TAPCELL_ROW_111_1585 VGND VPWR sky130_fd_sc_hd__tapvpwrvgnd_1
XFILLER_94_642 VGND VGND VPWR VPWR sky130_fd_sc_hd__fill_2
XFILLER_81_314 VGND VGND VPWR VPWR sky130_fd_sc_hd__decap_3
XFILLER_93_141 VGND VGND VPWR VPWR sky130_fd_sc_hd__decap_3
XFILLER_93_163 VGND VGND VPWR VPWR sky130_fd_sc_hd__decap_3
XFILLER_94_675 VGND VGND VPWR VPWR sky130_fd_sc_hd__decap_3
XFILLER_19_271 VGND VGND VPWR VPWR sky130_fd_sc_hd__decap_3
XFILLER_19_293 VGND VGND VPWR VPWR sky130_fd_sc_hd__decap_3
XFILLER_47_580 VGND VGND VPWR VPWR sky130_fd_sc_hd__fill_1
XFILLER_81_347 VGND VGND VPWR VPWR sky130_fd_sc_hd__decap_3
X_6941_ _7405_/CLK _6941_/D VGND VGND VPWR VPWR _6941_/Q sky130_fd_sc_hd__dfxtp_2
XFILLER_62_550 VGND VGND VPWR VPWR sky130_fd_sc_hd__decap_3
X_6872_ clkload2/A _6872_/D VGND VGND VPWR VPWR _6872_/Q sky130_fd_sc_hd__dfxtp_2
XTAP_TAPCELL_ROW_66_1042 VGND VPWR sky130_fd_sc_hd__tapvpwrvgnd_1
XTAP_TAPCELL_ROW_17_461 VGND VPWR sky130_fd_sc_hd__tapvpwrvgnd_1
XTAP_TAPCELL_ROW_17_450 VGND VPWR sky130_fd_sc_hd__tapvpwrvgnd_1
XTAP_TAPCELL_ROW_45_792 VGND VPWR sky130_fd_sc_hd__tapvpwrvgnd_1
XFILLER_22_469 VGND VGND VPWR VPWR sky130_fd_sc_hd__decap_3
XFILLER_30_491 VGND VGND VPWR VPWR sky130_fd_sc_hd__decap_3
X_4705_ _6995_/Q _6996_/Q _4963_/A VGND VGND VPWR VPWR _4931_/A sky130_fd_sc_hd__and3_2
XFILLER_8_80 VGND VGND VPWR VPWR sky130_fd_sc_hd__decap_3
XFILLER_8_91 VGND VGND VPWR VPWR sky130_fd_sc_hd__decap_3
X_4636_ _4186_/A _4636_/B VGND VGND VPWR VPWR _4639_/A sky130_fd_sc_hd__and2b_2
XPHY_EDGE_ROW_62_Left_179 VGND VGND VPWR VPWR sky130_fd_sc_hd__decap_3
X_7355_ _7384_/CLK _7355_/D _6635_/Y VGND VGND VPWR VPWR _7355_/Q sky130_fd_sc_hd__dfrtp_2
Xhold610 _6785_/Q VGND VGND VPWR VPWR _6785_/D sky130_fd_sc_hd__dlygate4sd3_1
Xhold621 _6802_/Q VGND VGND VPWR VPWR _6802_/D sky130_fd_sc_hd__dlygate4sd3_1
XFILLER_116_574 VGND VGND VPWR VPWR sky130_fd_sc_hd__decap_3
XFILLER_78_19 VGND VGND VPWR VPWR sky130_fd_sc_hd__decap_3
Xhold632 _6869_/Q VGND VGND VPWR VPWR _6869_/D sky130_fd_sc_hd__dlygate4sd3_1
Xhold643 _6840_/Q VGND VGND VPWR VPWR _6840_/D sky130_fd_sc_hd__dlygate4sd3_1
Xhold654 _6746_/Q VGND VGND VPWR VPWR _6746_/D sky130_fd_sc_hd__dlygate4sd3_1
X_6306_ _6525_/A VGND VGND VPWR VPWR _6306_/Y sky130_fd_sc_hd__inv_2
X_4567_ _4567_/A _4571_/B VGND VGND VPWR VPWR _7297_/D sky130_fd_sc_hd__and2_2
XTAP_TAPCELL_ROW_77_1171 VGND VPWR sky130_fd_sc_hd__tapvpwrvgnd_1
XFILLER_89_436 VGND VGND VPWR VPWR sky130_fd_sc_hd__decap_3
X_7286_ clkload4/A _7286_/D _6566_/Y VGND VGND VPWR VPWR _7286_/Q sky130_fd_sc_hd__dfrtp_2
Xhold665 _6787_/Q VGND VGND VPWR VPWR _6787_/D sky130_fd_sc_hd__dlygate4sd3_1
Xhold676 _6720_/Q VGND VGND VPWR VPWR _6720_/D sky130_fd_sc_hd__dlygate4sd3_1
Xhold687 _6828_/Q VGND VGND VPWR VPWR _6828_/D sky130_fd_sc_hd__dlygate4sd3_1
Xhold698 _6844_/Q VGND VGND VPWR VPWR _6844_/D sky130_fd_sc_hd__dlygate4sd3_1
X_3449_ _3449_/A _3449_/B _3449_/C VGND VGND VPWR VPWR _3449_/X sky130_fd_sc_hd__and3_2
XFILLER_69_160 VGND VGND VPWR VPWR sky130_fd_sc_hd__decap_3
XFILLER_85_620 VGND VGND VPWR VPWR sky130_fd_sc_hd__decap_3
XFILLER_94_18 VGND VGND VPWR VPWR sky130_fd_sc_hd__decap_3
XFILLER_111_290 VGND VGND VPWR VPWR sky130_fd_sc_hd__decap_3
XFILLER_57_322 VGND VGND VPWR VPWR sky130_fd_sc_hd__decap_3
XFILLER_69_193 VGND VGND VPWR VPWR sky130_fd_sc_hd__decap_3
XFILLER_85_653 VGND VGND VPWR VPWR sky130_fd_sc_hd__decap_3
X_5119_ _4697_/A _5670_/B _6984_/Q VGND VGND VPWR VPWR _5120_/B sky130_fd_sc_hd__a21oi_2
XFILLER_17_219 VGND VGND VPWR VPWR sky130_fd_sc_hd__decap_3
XFILLER_27_12 VGND VGND VPWR VPWR sky130_fd_sc_hd__decap_3
XFILLER_27_45 VGND VGND VPWR VPWR sky130_fd_sc_hd__decap_3
XFILLER_57_355 VGND VGND VPWR VPWR sky130_fd_sc_hd__decap_3
XFILLER_84_141 VGND VGND VPWR VPWR sky130_fd_sc_hd__decap_3
XPHY_EDGE_ROW_71_Left_188 VGND VGND VPWR VPWR sky130_fd_sc_hd__decap_3
XFILLER_27_78 VGND VGND VPWR VPWR sky130_fd_sc_hd__decap_3
XFILLER_45_539 VGND VGND VPWR VPWR sky130_fd_sc_hd__decap_3
XFILLER_72_336 VGND VGND VPWR VPWR sky130_fd_sc_hd__decap_3
XFILLER_40_200 VGND VGND VPWR VPWR sky130_fd_sc_hd__fill_2
XFILLER_40_211 VGND VGND VPWR VPWR sky130_fd_sc_hd__decap_3
XFILLER_13_436 VGND VGND VPWR VPWR sky130_fd_sc_hd__fill_1
XFILLER_13_458 VGND VGND VPWR VPWR sky130_fd_sc_hd__decap_3
XFILLER_40_244 VGND VGND VPWR VPWR sky130_fd_sc_hd__decap_3
XPHY_EDGE_ROW_80_Left_197 VGND VGND VPWR VPWR sky130_fd_sc_hd__decap_3
XFILLER_4_112 VGND VGND VPWR VPWR sky130_fd_sc_hd__decap_3
XFILLER_4_156 VGND VGND VPWR VPWR sky130_fd_sc_hd__decap_3
XFILLER_5_668 VGND VGND VPWR VPWR sky130_fd_sc_hd__decap_3
XFILLER_5_679 VGND VGND VPWR VPWR sky130_fd_sc_hd__decap_3
XFILLER_4_27 VGND VGND VPWR VPWR sky130_fd_sc_hd__fill_1
XFILLER_4_38 VGND VGND VPWR VPWR sky130_fd_sc_hd__decap_3
XFILLER_68_41 VGND VGND VPWR VPWR sky130_fd_sc_hd__decap_3
XFILLER_68_52 VGND VGND VPWR VPWR sky130_fd_sc_hd__decap_3
XFILLER_0_340 VGND VGND VPWR VPWR sky130_fd_sc_hd__fill_2
XFILLER_0_362 VGND VGND VPWR VPWR sky130_fd_sc_hd__fill_2
XFILLER_67_108 VGND VGND VPWR VPWR sky130_fd_sc_hd__decap_3
XFILLER_68_74 VGND VGND VPWR VPWR sky130_fd_sc_hd__decap_3
XFILLER_68_85 VGND VGND VPWR VPWR sky130_fd_sc_hd__decap_3
XFILLER_95_417 VGND VGND VPWR VPWR sky130_fd_sc_hd__decap_3
XFILLER_76_642 VGND VGND VPWR VPWR sky130_fd_sc_hd__fill_2
XFILLER_48_377 VGND VGND VPWR VPWR sky130_fd_sc_hd__decap_3
XFILLER_75_163 VGND VGND VPWR VPWR sky130_fd_sc_hd__decap_3
XFILLER_76_675 VGND VGND VPWR VPWR sky130_fd_sc_hd__decap_3
XFILLER_91_612 VGND VGND VPWR VPWR sky130_fd_sc_hd__decap_3
XFILLER_90_100 VGND VGND VPWR VPWR sky130_fd_sc_hd__decap_3
XFILLER_91_623 VGND VGND VPWR VPWR sky130_fd_sc_hd__decap_3
Xplace303 _3605_/Y VGND VGND VPWR VPWR _4811_/C sky130_fd_sc_hd__buf_2
XFILLER_16_241 VGND VGND VPWR VPWR sky130_fd_sc_hd__fill_2
XFILLER_44_550 VGND VGND VPWR VPWR sky130_fd_sc_hd__fill_1
XFILLER_63_358 VGND VGND VPWR VPWR sky130_fd_sc_hd__decap_3
XFILLER_90_144 VGND VGND VPWR VPWR sky130_fd_sc_hd__decap_3
XFILLER_91_656 VGND VGND VPWR VPWR sky130_fd_sc_hd__decap_3
Xplace336 _4262_/A2 VGND VGND VPWR VPWR _4349_/B1 sky130_fd_sc_hd__buf_2
Xplace325 _4460_/A VGND VGND VPWR VPWR _4205_/A sky130_fd_sc_hd__buf_2
Xplace314 _5274_/S VGND VGND VPWR VPWR _5292_/S sky130_fd_sc_hd__buf_2
XFILLER_90_177 VGND VGND VPWR VPWR sky130_fd_sc_hd__decap_3
Xplace369 _3347_/B VGND VGND VPWR VPWR _3509_/B sky130_fd_sc_hd__buf_2
Xplace358 _3415_/X VGND VGND VPWR VPWR _5159_/S sky130_fd_sc_hd__buf_2
Xplace347 _4337_/B VGND VGND VPWR VPWR _4272_/B sky130_fd_sc_hd__buf_2
XFILLER_31_211 VGND VGND VPWR VPWR sky130_fd_sc_hd__fill_2
XTAP_TAPCELL_ROW_14_420 VGND VPWR sky130_fd_sc_hd__tapvpwrvgnd_1
XFILLER_31_255 VGND VGND VPWR VPWR sky130_fd_sc_hd__fill_2
XTAP_TAPCELL_ROW_42_751 VGND VPWR sky130_fd_sc_hd__tapvpwrvgnd_1
XFILLER_12_480 VGND VGND VPWR VPWR sky130_fd_sc_hd__fill_2
XFILLER_8_451 VGND VGND VPWR VPWR sky130_fd_sc_hd__decap_3
XFILLER_69_3 VGND VGND VPWR VPWR sky130_fd_sc_hd__decap_3
X_4421_ _7240_/Q _4430_/A2 _4430_/B1 _7176_/Q _4420_/X VGND VGND VPWR VPWR _4421_/X
+ sky130_fd_sc_hd__a221o_2
XTAP_TAPCELL_ROW_113_1603 VGND VPWR sky130_fd_sc_hd__tapvpwrvgnd_1
XFILLER_113_500 VGND VGND VPWR VPWR sky130_fd_sc_hd__decap_3
X_7140_ _7334_/CLK _7140_/D _6420_/Y VGND VGND VPWR VPWR _7140_/Q sky130_fd_sc_hd__dfrtp_2
X_4352_ _7289_/Q _4946_/S _4352_/B1 _7161_/Q _4351_/X VGND VGND VPWR VPWR _4352_/X
+ sky130_fd_sc_hd__a221o_2
XFILLER_113_544 VGND VGND VPWR VPWR sky130_fd_sc_hd__decap_3
XFILLER_4_690 VGND VGND VPWR VPWR sky130_fd_sc_hd__fill_2
X_7071_ _7265_/CLK _7071_/D _6351_/Y VGND VGND VPWR VPWR _7071_/Q sky130_fd_sc_hd__dfrtp_2
X_4283_ _7094_/Q _4351_/A2 _4351_/B1 _7126_/Q VGND VGND VPWR VPWR _4283_/X sky130_fd_sc_hd__a22o_2
X_3303_ _4467_/A _3519_/B _3302_/X VGND VGND VPWR VPWR _6981_/D sky130_fd_sc_hd__o21a_4
XFILLER_113_588 VGND VGND VPWR VPWR sky130_fd_sc_hd__decap_3
XFILLER_100_238 VGND VGND VPWR VPWR sky130_fd_sc_hd__decap_3
XFILLER_39_311 VGND VGND VPWR VPWR sky130_fd_sc_hd__decap_3
XFILLER_67_620 VGND VGND VPWR VPWR sky130_fd_sc_hd__decap_3
XFILLER_67_653 VGND VGND VPWR VPWR sky130_fd_sc_hd__decap_3
XFILLER_66_141 VGND VGND VPWR VPWR sky130_fd_sc_hd__decap_3
XFILLER_82_601 VGND VGND VPWR VPWR sky130_fd_sc_hd__decap_3
XFILLER_94_472 VGND VGND VPWR VPWR sky130_fd_sc_hd__decap_3
XFILLER_27_528 VGND VGND VPWR VPWR sky130_fd_sc_hd__decap_3
XFILLER_66_174 VGND VGND VPWR VPWR sky130_fd_sc_hd__decap_3
XFILLER_81_122 VGND VGND VPWR VPWR sky130_fd_sc_hd__decap_3
XFILLER_82_634 VGND VGND VPWR VPWR sky130_fd_sc_hd__decap_3
XFILLER_82_645 VGND VGND VPWR VPWR sky130_fd_sc_hd__decap_3
XFILLER_81_155 VGND VGND VPWR VPWR sky130_fd_sc_hd__decap_3
XFILLER_82_678 VGND VGND VPWR VPWR sky130_fd_sc_hd__decap_3
X_6924_ _7392_/CLK _6924_/D VGND VGND VPWR VPWR _6924_/Q sky130_fd_sc_hd__dfxtp_2
XFILLER_22_200 VGND VGND VPWR VPWR sky130_fd_sc_hd__decap_3
XFILLER_50_531 VGND VGND VPWR VPWR sky130_fd_sc_hd__fill_1
Xfanout26 _6664_/A VGND VGND VPWR VPWR _6562_/A sky130_fd_sc_hd__buf_2
Xfanout37 fanout38/X VGND VGND VPWR VPWR _6644_/A sky130_fd_sc_hd__buf_2
X_6855_ _6946_/CLK _6855_/D VGND VGND VPWR VPWR _6855_/Q sky130_fd_sc_hd__dfxtp_2
XFILLER_10_406 VGND VGND VPWR VPWR sky130_fd_sc_hd__decap_3
XFILLER_13_14 VGND VGND VPWR VPWR sky130_fd_sc_hd__decap_3
XFILLER_50_586 VGND VGND VPWR VPWR sky130_fd_sc_hd__fill_2
Xfanout48 fanout51/X VGND VGND VPWR VPWR _6385_/A sky130_fd_sc_hd__buf_2
Xfanout59 _6616_/A VGND VGND VPWR VPWR _6675_/A sky130_fd_sc_hd__buf_2
X_6786_ _6975_/CLK _6786_/D VGND VGND VPWR VPWR _6786_/Q sky130_fd_sc_hd__dfxtp_2
XFILLER_13_47 VGND VGND VPWR VPWR sky130_fd_sc_hd__decap_3
XFILLER_22_288 VGND VGND VPWR VPWR sky130_fd_sc_hd__decap_3
XFILLER_50_597 VGND VGND VPWR VPWR sky130_fd_sc_hd__decap_3
X_5737_ _7374_/Q hold972/X _5737_/S VGND VGND VPWR VPWR _5737_/X sky130_fd_sc_hd__mux2_2
XTAP_TAPCELL_ROW_79_1200 VGND VPWR sky130_fd_sc_hd__tapvpwrvgnd_1
XFILLER_108_316 VGND VGND VPWR VPWR sky130_fd_sc_hd__decap_3
XFILLER_13_69 VGND VGND VPWR VPWR sky130_fd_sc_hd__decap_3
XFILLER_108_327 VGND VGND VPWR VPWR sky130_fd_sc_hd__fill_2
XFILLER_108_338 VGND VGND VPWR VPWR sky130_fd_sc_hd__fill_1
XFILLER_89_18 VGND VGND VPWR VPWR sky130_fd_sc_hd__decap_3
X_5668_ _5668_/A _5668_/B VGND VGND VPWR VPWR _6980_/D sky130_fd_sc_hd__or2_2
XTAP_TAPCELL_ROW_20_489 VGND VPWR sky130_fd_sc_hd__tapvpwrvgnd_1
X_4619_ _5086_/A _4619_/B _5101_/B _5073_/A VGND VGND VPWR VPWR _4619_/Y sky130_fd_sc_hd__nor4_1
XFILLER_116_371 VGND VGND VPWR VPWR sky130_fd_sc_hd__decap_3
XFILLER_116_382 VGND VGND VPWR VPWR sky130_fd_sc_hd__decap_3
XFILLER_2_627 VGND VGND VPWR VPWR sky130_fd_sc_hd__decap_3
X_7338_ _7402_/CLK _7338_/D _6618_/Y VGND VGND VPWR VPWR _7338_/Q sky130_fd_sc_hd__dfrtp_2
XFILLER_104_544 VGND VGND VPWR VPWR sky130_fd_sc_hd__decap_3
XFILLER_116_393 VGND VGND VPWR VPWR sky130_fd_sc_hd__decap_3
XFILLER_1_137 VGND VGND VPWR VPWR sky130_fd_sc_hd__decap_3
X_7269_ _7368_/CLK _7269_/D _6549_/Y VGND VGND VPWR VPWR _7269_/Q sky130_fd_sc_hd__dfrtp_2
XFILLER_49_119 VGND VGND VPWR VPWR sky130_fd_sc_hd__decap_3
XFILLER_89_266 VGND VGND VPWR VPWR sky130_fd_sc_hd__decap_3
XFILLER_58_631 VGND VGND VPWR VPWR sky130_fd_sc_hd__decap_3
XFILLER_38_66 VGND VGND VPWR VPWR sky130_fd_sc_hd__decap_3
XFILLER_57_141 VGND VGND VPWR VPWR sky130_fd_sc_hd__decap_3
XFILLER_58_675 VGND VGND VPWR VPWR sky130_fd_sc_hd__decap_3
XFILLER_85_461 VGND VGND VPWR VPWR sky130_fd_sc_hd__fill_2
Xhold1140 _7137_/Q VGND VGND VPWR VPWR _5392_/A0 sky130_fd_sc_hd__dlygate4sd3_1
Xhold1151 _7302_/Q VGND VGND VPWR VPWR _4556_/A sky130_fd_sc_hd__dlygate4sd3_1
XFILLER_38_99 VGND VGND VPWR VPWR sky130_fd_sc_hd__decap_3
XFILLER_73_623 VGND VGND VPWR VPWR sky130_fd_sc_hd__decap_3
Xhold1162 _7148_/Q VGND VGND VPWR VPWR _5369_/A0 sky130_fd_sc_hd__dlygate4sd3_1
Xhold1173 _7139_/Q VGND VGND VPWR VPWR _5388_/A0 sky130_fd_sc_hd__dlygate4sd3_1
Xhold1184 _7132_/Q VGND VGND VPWR VPWR _5402_/A0 sky130_fd_sc_hd__dlygate4sd3_1
XFILLER_33_509 VGND VGND VPWR VPWR sky130_fd_sc_hd__decap_3
XFILLER_45_369 VGND VGND VPWR VPWR sky130_fd_sc_hd__decap_3
XFILLER_54_21 VGND VGND VPWR VPWR sky130_fd_sc_hd__decap_3
XFILLER_73_656 VGND VGND VPWR VPWR sky130_fd_sc_hd__decap_3
Xhold1195 _7216_/Q VGND VGND VPWR VPWR _5225_/A sky130_fd_sc_hd__dlygate4sd3_1
XFILLER_54_65 VGND VGND VPWR VPWR sky130_fd_sc_hd__decap_3
XFILLER_72_177 VGND VGND VPWR VPWR sky130_fd_sc_hd__decap_3
XTAP_TAPCELL_ROW_28_589 VGND VPWR sky130_fd_sc_hd__tapvpwrvgnd_1
XFILLER_13_211 VGND VGND VPWR VPWR sky130_fd_sc_hd__decap_3
XFILLER_13_222 VGND VGND VPWR VPWR sky130_fd_sc_hd__fill_2
XPHY_EDGE_ROW_109_Left_226 VGND VGND VPWR VPWR sky130_fd_sc_hd__decap_3
XFILLER_110_71 VGND VGND VPWR VPWR sky130_fd_sc_hd__decap_3
XFILLER_41_564 VGND VGND VPWR VPWR sky130_fd_sc_hd__decap_3
XFILLER_70_64 VGND VGND VPWR VPWR sky130_fd_sc_hd__decap_3
Xclkload18 _6944_/CLK VGND VGND VPWR VPWR clkload18/Y sky130_fd_sc_hd__clkinv_4
Xclkload29 _7405_/CLK VGND VGND VPWR VPWR clkload29/X sky130_fd_sc_hd__clkbuf_1
XFILLER_55_9 VGND VGND VPWR VPWR sky130_fd_sc_hd__decap_3
XFILLER_5_432 VGND VGND VPWR VPWR sky130_fd_sc_hd__decap_3
XFILLER_107_360 VGND VGND VPWR VPWR sky130_fd_sc_hd__fill_1
XFILLER_107_382 VGND VGND VPWR VPWR sky130_fd_sc_hd__fill_1
XFILLER_107_393 VGND VGND VPWR VPWR sky130_fd_sc_hd__fill_2
XFILLER_79_84 VGND VGND VPWR VPWR sky130_fd_sc_hd__decap_3
XFILLER_1_682 VGND VGND VPWR VPWR sky130_fd_sc_hd__fill_2
XFILLER_49_620 VGND VGND VPWR VPWR sky130_fd_sc_hd__decap_3
XFILLER_95_225 VGND VGND VPWR VPWR sky130_fd_sc_hd__decap_3
XFILLER_0_192 VGND VGND VPWR VPWR sky130_fd_sc_hd__decap_3
XFILLER_110_569 VGND VGND VPWR VPWR sky130_fd_sc_hd__decap_3
XFILLER_48_141 VGND VGND VPWR VPWR sky130_fd_sc_hd__decap_3
XFILLER_49_653 VGND VGND VPWR VPWR sky130_fd_sc_hd__decap_3
XFILLER_64_601 VGND VGND VPWR VPWR sky130_fd_sc_hd__decap_3
XFILLER_95_72 VGND VGND VPWR VPWR sky130_fd_sc_hd__decap_3
XFILLER_95_83 VGND VGND VPWR VPWR sky130_fd_sc_hd__decap_3
XFILLER_63_111 VGND VGND VPWR VPWR sky130_fd_sc_hd__fill_1
XFILLER_64_634 VGND VGND VPWR VPWR sky130_fd_sc_hd__decap_3
XFILLER_64_645 VGND VGND VPWR VPWR sky130_fd_sc_hd__decap_3
XTAP_TAPCELL_ROW_47_821 VGND VPWR sky130_fd_sc_hd__tapvpwrvgnd_1
XTAP_TAPCELL_ROW_47_810 VGND VPWR sky130_fd_sc_hd__tapvpwrvgnd_1
XFILLER_24_509 VGND VGND VPWR VPWR sky130_fd_sc_hd__decap_3
XFILLER_63_155 VGND VGND VPWR VPWR sky130_fd_sc_hd__decap_3
XFILLER_64_678 VGND VGND VPWR VPWR sky130_fd_sc_hd__decap_3
XFILLER_17_561 VGND VGND VPWR VPWR sky130_fd_sc_hd__decap_3
XFILLER_63_177 VGND VGND VPWR VPWR sky130_fd_sc_hd__decap_3
X_4970_ _3526_/B _4950_/B _4967_/B _5033_/B2 VGND VGND VPWR VPWR _4970_/X sky130_fd_sc_hd__a22o_2
X_3921_ _6914_/Q _3926_/A2 _3925_/A2 _6688_/Q VGND VGND VPWR VPWR _3921_/X sky130_fd_sc_hd__a22o_2
XTAP_TAPCELL_ROW_63_1012 VGND VPWR sky130_fd_sc_hd__tapvpwrvgnd_1
X_6640_ _6640_/A VGND VGND VPWR VPWR _6640_/Y sky130_fd_sc_hd__inv_2
X_3852_ _6748_/Q _3906_/A2 _3665_/X _6742_/Q VGND VGND VPWR VPWR _3852_/X sky130_fd_sc_hd__a22o_2
X_6571_ _6632_/A VGND VGND VPWR VPWR _6571_/Y sky130_fd_sc_hd__inv_2
X_3783_ _6812_/Q _3893_/B1 _3665_/X _6822_/Q _3782_/X VGND VGND VPWR VPWR _3783_/X
+ sky130_fd_sc_hd__a221o_2
XFILLER_8_270 VGND VGND VPWR VPWR sky130_fd_sc_hd__fill_2
Xoutput501 _3394_/A VGND VGND VPWR VPWR instruction_out[16] sky130_fd_sc_hd__clkdlybuf4s25_1
Xoutput545 _7007_/Q VGND VGND VPWR VPWR pc_out[30] sky130_fd_sc_hd__clkdlybuf4s25_1
Xoutput534 _6997_/Q VGND VGND VPWR VPWR pc_out[20] sky130_fd_sc_hd__clkdlybuf4s25_1
Xoutput523 _6987_/Q VGND VGND VPWR VPWR pc_out[10] sky130_fd_sc_hd__clkdlybuf4s25_1
Xoutput512 _4671_/B VGND VGND VPWR VPWR instruction_out[28] sky130_fd_sc_hd__clkdlybuf4s25_1
X_4404_ _7306_/Q _4901_/S _4434_/A2 _7114_/Q VGND VGND VPWR VPWR _4404_/X sky130_fd_sc_hd__a22o_2
XFILLER_5_81 VGND VGND VPWR VPWR sky130_fd_sc_hd__decap_3
X_7123_ clkload3/A _7123_/D _6403_/Y VGND VGND VPWR VPWR _7123_/Q sky130_fd_sc_hd__dfrtp_2
X_4335_ _7287_/Q _5136_/S _3417_/X _7095_/Q VGND VGND VPWR VPWR _4336_/C sky130_fd_sc_hd__a22o_2
XTAP_TAPCELL_ROW_74_1141 VGND VPWR sky130_fd_sc_hd__tapvpwrvgnd_1
XFILLER_99_542 VGND VGND VPWR VPWR sky130_fd_sc_hd__decap_3
XFILLER_86_203 VGND VGND VPWR VPWR sky130_fd_sc_hd__decap_3
XFILLER_99_575 VGND VGND VPWR VPWR sky130_fd_sc_hd__decap_3
XFILLER_113_396 VGND VGND VPWR VPWR sky130_fd_sc_hd__decap_3
XFILLER_115_38 VGND VGND VPWR VPWR sky130_fd_sc_hd__decap_3
XFILLER_86_225 VGND VGND VPWR VPWR sky130_fd_sc_hd__decap_3
X_7054_ _7374_/CLK _7054_/D _6334_/Y VGND VGND VPWR VPWR _7054_/Q sky130_fd_sc_hd__dfrtp_2
X_4266_ _7294_/Q _5159_/S _4351_/A2 _7102_/Q VGND VGND VPWR VPWR _4271_/A sky130_fd_sc_hd__a22o_2
XFILLER_74_409 VGND VGND VPWR VPWR sky130_fd_sc_hd__decap_3
X_4197_ _7199_/Q _3962_/S _4505_/S _7044_/Q _4196_/X VGND VGND VPWR VPWR _4197_/X
+ sky130_fd_sc_hd__a221o_2
XFILLER_27_314 VGND VGND VPWR VPWR sky130_fd_sc_hd__decap_3
XFILLER_39_163 VGND VGND VPWR VPWR sky130_fd_sc_hd__decap_3
XFILLER_55_612 VGND VGND VPWR VPWR sky130_fd_sc_hd__decap_3
XFILLER_55_623 VGND VGND VPWR VPWR sky130_fd_sc_hd__decap_3
XFILLER_67_472 VGND VGND VPWR VPWR sky130_fd_sc_hd__decap_3
XFILLER_94_280 VGND VGND VPWR VPWR sky130_fd_sc_hd__decap_3
XFILLER_27_358 VGND VGND VPWR VPWR sky130_fd_sc_hd__decap_3
XFILLER_54_144 VGND VGND VPWR VPWR sky130_fd_sc_hd__decap_3
XFILLER_55_656 VGND VGND VPWR VPWR sky130_fd_sc_hd__decap_3
XFILLER_42_306 VGND VGND VPWR VPWR sky130_fd_sc_hd__fill_2
XFILLER_54_177 VGND VGND VPWR VPWR sky130_fd_sc_hd__decap_3
XFILLER_70_604 VGND VGND VPWR VPWR sky130_fd_sc_hd__decap_3
XFILLER_70_637 VGND VGND VPWR VPWR sky130_fd_sc_hd__decap_3
XFILLER_23_531 VGND VGND VPWR VPWR sky130_fd_sc_hd__decap_3
XFILLER_70_648 VGND VGND VPWR VPWR sky130_fd_sc_hd__decap_3
X_6907_ _6946_/CLK _6907_/D VGND VGND VPWR VPWR _6907_/Q sky130_fd_sc_hd__dfxtp_2
XTAP_TAPCELL_ROW_85_1270 VGND VPWR sky130_fd_sc_hd__tapvpwrvgnd_1
XTAP_TAPCELL_ROW_25_548 VGND VPWR sky130_fd_sc_hd__tapvpwrvgnd_1
XFILLER_23_564 VGND VGND VPWR VPWR sky130_fd_sc_hd__decap_3
XFILLER_24_57 VGND VGND VPWR VPWR sky130_fd_sc_hd__decap_3
X_6838_ _6978_/CLK _6838_/D VGND VGND VPWR VPWR _6838_/Q sky130_fd_sc_hd__dfxtp_2
XFILLER_10_203 VGND VGND VPWR VPWR sky130_fd_sc_hd__decap_3
XFILLER_24_79 VGND VGND VPWR VPWR sky130_fd_sc_hd__decap_3
XFILLER_109_603 VGND VGND VPWR VPWR sky130_fd_sc_hd__decap_3
X_6769_ _6971_/CLK _6769_/D VGND VGND VPWR VPWR _6769_/Q sky130_fd_sc_hd__dfxtp_2
XFILLER_108_124 VGND VGND VPWR VPWR sky130_fd_sc_hd__decap_3
XFILLER_109_647 VGND VGND VPWR VPWR sky130_fd_sc_hd__decap_3
XFILLER_40_12 VGND VGND VPWR VPWR sky130_fd_sc_hd__decap_3
XFILLER_2_413 VGND VGND VPWR VPWR sky130_fd_sc_hd__decap_3
XFILLER_104_330 VGND VGND VPWR VPWR sky130_fd_sc_hd__decap_3
XFILLER_116_190 VGND VGND VPWR VPWR sky130_fd_sc_hd__decap_3
XFILLER_2_424 VGND VGND VPWR VPWR sky130_fd_sc_hd__decap_3
XFILLER_2_457 VGND VGND VPWR VPWR sky130_fd_sc_hd__decap_3
XFILLER_49_21 VGND VGND VPWR VPWR sky130_fd_sc_hd__decap_3
XFILLER_104_352 VGND VGND VPWR VPWR sky130_fd_sc_hd__decap_3
XFILLER_104_374 VGND VGND VPWR VPWR sky130_fd_sc_hd__decap_3
XFILLER_77_225 VGND VGND VPWR VPWR sky130_fd_sc_hd__decap_3
XFILLER_1_17 VGND VGND VPWR VPWR sky130_fd_sc_hd__decap_3
XFILLER_77_269 VGND VGND VPWR VPWR sky130_fd_sc_hd__decap_3
XFILLER_46_623 VGND VGND VPWR VPWR sky130_fd_sc_hd__decap_3
XFILLER_58_472 VGND VGND VPWR VPWR sky130_fd_sc_hd__decap_3
XFILLER_18_336 VGND VGND VPWR VPWR sky130_fd_sc_hd__decap_3
XFILLER_45_122 VGND VGND VPWR VPWR sky130_fd_sc_hd__decap_3
XFILLER_46_645 VGND VGND VPWR VPWR sky130_fd_sc_hd__decap_3
XFILLER_65_75 VGND VGND VPWR VPWR sky130_fd_sc_hd__decap_3
XFILLER_46_678 VGND VGND VPWR VPWR sky130_fd_sc_hd__decap_3
XFILLER_61_626 VGND VGND VPWR VPWR sky130_fd_sc_hd__decap_3
XFILLER_73_486 VGND VGND VPWR VPWR sky130_fd_sc_hd__decap_3
XFILLER_26_391 VGND VGND VPWR VPWR sky130_fd_sc_hd__decap_3
XFILLER_60_114 VGND VGND VPWR VPWR sky130_fd_sc_hd__decap_3
XFILLER_61_659 VGND VGND VPWR VPWR sky130_fd_sc_hd__decap_3
XTAP_TAPCELL_ROW_99_1439 VGND VPWR sky130_fd_sc_hd__tapvpwrvgnd_1
XFILLER_115_606 VGND VGND VPWR VPWR sky130_fd_sc_hd__decap_3
XFILLER_115_617 VGND VGND VPWR VPWR sky130_fd_sc_hd__decap_3
XPHY_EDGE_ROW_116_Right_116 VGND VGND VPWR VPWR sky130_fd_sc_hd__decap_3
XFILLER_114_127 VGND VGND VPWR VPWR sky130_fd_sc_hd__decap_3
XFILLER_53_6 VGND VGND VPWR VPWR sky130_fd_sc_hd__decap_3
XFILLER_107_190 VGND VGND VPWR VPWR sky130_fd_sc_hd__decap_3
XFILLER_68_203 VGND VGND VPWR VPWR sky130_fd_sc_hd__decap_3
XFILLER_96_512 VGND VGND VPWR VPWR sky130_fd_sc_hd__decap_3
XFILLER_68_214 VGND VGND VPWR VPWR sky130_fd_sc_hd__decap_3
XFILLER_68_236 VGND VGND VPWR VPWR sky130_fd_sc_hd__decap_3
XFILLER_96_545 VGND VGND VPWR VPWR sky130_fd_sc_hd__decap_3
X_4120_ _7300_/Q _4946_/S _4250_/A2 _7108_/Q VGND VGND VPWR VPWR _4120_/X sky130_fd_sc_hd__a22o_2
XFILLER_110_344 VGND VGND VPWR VPWR sky130_fd_sc_hd__decap_3
XFILLER_96_589 VGND VGND VPWR VPWR sky130_fd_sc_hd__fill_1
XFILLER_110_377 VGND VGND VPWR VPWR sky130_fd_sc_hd__decap_3
XFILLER_37_612 VGND VGND VPWR VPWR sky130_fd_sc_hd__decap_3
XFILLER_36_122 VGND VGND VPWR VPWR sky130_fd_sc_hd__decap_3
XFILLER_76_291 VGND VGND VPWR VPWR sky130_fd_sc_hd__fill_2
XTAP_TAPCELL_ROW_108_1546 VGND VPWR sky130_fd_sc_hd__tapvpwrvgnd_1
XFILLER_36_155 VGND VGND VPWR VPWR sky130_fd_sc_hd__decap_3
XFILLER_52_604 VGND VGND VPWR VPWR sky130_fd_sc_hd__decap_3
XFILLER_64_475 VGND VGND VPWR VPWR sky130_fd_sc_hd__fill_1
XFILLER_101_29 VGND VGND VPWR VPWR sky130_fd_sc_hd__decap_3
XFILLER_17_391 VGND VGND VPWR VPWR sky130_fd_sc_hd__fill_1
XFILLER_24_328 VGND VGND VPWR VPWR sky130_fd_sc_hd__fill_2
XFILLER_52_637 VGND VGND VPWR VPWR sky130_fd_sc_hd__decap_3
XFILLER_52_648 VGND VGND VPWR VPWR sky130_fd_sc_hd__decap_3
X_4953_ _4950_/A _4381_/A _4969_/C _4814_/A VGND VGND VPWR VPWR _4953_/Y sky130_fd_sc_hd__a31oi_2
XFILLER_51_158 VGND VGND VPWR VPWR sky130_fd_sc_hd__decap_3
XFILLER_51_169 VGND VGND VPWR VPWR sky130_fd_sc_hd__decap_3
X_3904_ _5151_/A _3904_/B VGND VGND VPWR VPWR _3904_/Y sky130_fd_sc_hd__nand2_2
XFILLER_60_681 VGND VGND VPWR VPWR sky130_fd_sc_hd__decap_3
X_6623_ _6672_/A VGND VGND VPWR VPWR _6623_/Y sky130_fd_sc_hd__inv_2
X_4884_ _4884_/A _4904_/B VGND VGND VPWR VPWR _4884_/X sky130_fd_sc_hd__or2_2
XTAP_TAPCELL_ROW_50_849 VGND VPWR sky130_fd_sc_hd__tapvpwrvgnd_1
XTAP_TAPCELL_ROW_22_518 VGND VPWR sky130_fd_sc_hd__tapvpwrvgnd_1
X_3835_ _6725_/Q _3886_/A2 _3886_/B1 _6975_/Q VGND VGND VPWR VPWR _3835_/X sky130_fd_sc_hd__a22o_2
XFILLER_20_589 VGND VGND VPWR VPWR sky130_fd_sc_hd__decap_3
X_6554_ _6584_/A VGND VGND VPWR VPWR _6554_/Y sky130_fd_sc_hd__inv_2
X_3766_ _3766_/A1 _4791_/A1 _4927_/B VGND VGND VPWR VPWR _7394_/D sky130_fd_sc_hd__a21o_2
XFILLER_106_606 VGND VGND VPWR VPWR sky130_fd_sc_hd__decap_3
X_6485_ _6616_/A VGND VGND VPWR VPWR _6485_/Y sky130_fd_sc_hd__inv_2
XFILLER_9_590 VGND VGND VPWR VPWR sky130_fd_sc_hd__decap_3
XFILLER_105_105 VGND VGND VPWR VPWR sky130_fd_sc_hd__fill_2
XFILLER_106_639 VGND VGND VPWR VPWR sky130_fd_sc_hd__decap_3
XFILLER_10_15 VGND VGND VPWR VPWR sky130_fd_sc_hd__decap_3
X_3697_ _3629_/A _3696_/X _3442_/A VGND VGND VPWR VPWR _3697_/Y sky130_fd_sc_hd__a21oi_2
XFILLER_10_59 VGND VGND VPWR VPWR sky130_fd_sc_hd__decap_3
XFILLER_114_672 VGND VGND VPWR VPWR sky130_fd_sc_hd__decap_3
XFILLER_87_501 VGND VGND VPWR VPWR sky130_fd_sc_hd__decap_3
X_5367_ _5367_/A0 _4734_/X _5386_/S VGND VGND VPWR VPWR _7149_/D sky130_fd_sc_hd__mux2_2
XFILLER_99_372 VGND VGND VPWR VPWR sky130_fd_sc_hd__decap_3
XFILLER_99_350 VGND VGND VPWR VPWR sky130_fd_sc_hd__decap_3
XFILLER_101_322 VGND VGND VPWR VPWR sky130_fd_sc_hd__decap_3
XFILLER_59_225 VGND VGND VPWR VPWR sky130_fd_sc_hd__decap_3
XFILLER_59_236 VGND VGND VPWR VPWR sky130_fd_sc_hd__decap_3
X_7106_ _7266_/CLK _7106_/D _6386_/Y VGND VGND VPWR VPWR _7106_/Q sky130_fd_sc_hd__dfrtp_2
X_5298_ _5298_/A0 _4734_/X _5315_/S VGND VGND VPWR VPWR _7181_/D sky130_fd_sc_hd__mux2_2
X_4318_ _7290_/Q _4517_/S _3366_/X _7162_/Q _4317_/X VGND VGND VPWR VPWR _4318_/X
+ sky130_fd_sc_hd__a221o_2
XFILLER_101_355 VGND VGND VPWR VPWR sky130_fd_sc_hd__decap_3
XFILLER_113_193 VGND VGND VPWR VPWR sky130_fd_sc_hd__decap_3
XFILLER_19_35 VGND VGND VPWR VPWR sky130_fd_sc_hd__decap_3
X_7037_ _7352_/CLK _7037_/D _6317_/Y VGND VGND VPWR VPWR _7037_/Q sky130_fd_sc_hd__dfrtp_2
X_4249_ _7069_/Q _4265_/B _4205_/A VGND VGND VPWR VPWR _4626_/C sky130_fd_sc_hd__o21a_2
XFILLER_101_377 VGND VGND VPWR VPWR sky130_fd_sc_hd__decap_3
XFILLER_19_57 VGND VGND VPWR VPWR sky130_fd_sc_hd__decap_3
XFILLER_74_206 VGND VGND VPWR VPWR sky130_fd_sc_hd__decap_3
XFILLER_74_239 VGND VGND VPWR VPWR sky130_fd_sc_hd__decap_3
XTAP_TAPCELL_ROW_58_949 VGND VPWR sky130_fd_sc_hd__tapvpwrvgnd_1
XFILLER_27_122 VGND VGND VPWR VPWR sky130_fd_sc_hd__decap_3
XFILLER_28_645 VGND VGND VPWR VPWR sky130_fd_sc_hd__decap_3
XFILLER_67_291 VGND VGND VPWR VPWR sky130_fd_sc_hd__decap_3
XFILLER_15_317 VGND VGND VPWR VPWR sky130_fd_sc_hd__decap_3
XFILLER_27_177 VGND VGND VPWR VPWR sky130_fd_sc_hd__decap_3
XFILLER_43_604 VGND VGND VPWR VPWR sky130_fd_sc_hd__fill_2
XFILLER_55_464 VGND VGND VPWR VPWR sky130_fd_sc_hd__decap_3
XFILLER_70_401 VGND VGND VPWR VPWR sky130_fd_sc_hd__decap_3
XFILLER_70_412 VGND VGND VPWR VPWR sky130_fd_sc_hd__decap_3
XTAP_TAPCELL_ROW_2_276 VGND VPWR sky130_fd_sc_hd__tapvpwrvgnd_1
XFILLER_70_445 VGND VGND VPWR VPWR sky130_fd_sc_hd__decap_3
XFILLER_23_350 VGND VGND VPWR VPWR sky130_fd_sc_hd__decap_3
XFILLER_30_309 VGND VGND VPWR VPWR sky130_fd_sc_hd__decap_3
XFILLER_42_147 VGND VGND VPWR VPWR sky130_fd_sc_hd__decap_3
XFILLER_70_489 VGND VGND VPWR VPWR sky130_fd_sc_hd__decap_3
XFILLER_50_191 VGND VGND VPWR VPWR sky130_fd_sc_hd__decap_3
XFILLER_109_411 VGND VGND VPWR VPWR sky130_fd_sc_hd__decap_3
XFILLER_51_66 VGND VGND VPWR VPWR sky130_fd_sc_hd__decap_3
XFILLER_7_516 VGND VGND VPWR VPWR sky130_fd_sc_hd__fill_2
XFILLER_109_455 VGND VGND VPWR VPWR sky130_fd_sc_hd__fill_2
XFILLER_105_650 VGND VGND VPWR VPWR sky130_fd_sc_hd__decap_3
XFILLER_111_108 VGND VGND VPWR VPWR sky130_fd_sc_hd__decap_3
XFILLER_111_119 VGND VGND VPWR VPWR sky130_fd_sc_hd__decap_3
XFILLER_76_41 VGND VGND VPWR VPWR sky130_fd_sc_hd__fill_2
XFILLER_18_9 VGND VGND VPWR VPWR sky130_fd_sc_hd__decap_3
XFILLER_76_74 VGND VGND VPWR VPWR sky130_fd_sc_hd__decap_3
XFILLER_76_85 VGND VGND VPWR VPWR sky130_fd_sc_hd__decap_3
XFILLER_78_589 VGND VGND VPWR VPWR sky130_fd_sc_hd__decap_3
XFILLER_58_280 VGND VGND VPWR VPWR sky130_fd_sc_hd__fill_2
XFILLER_93_559 VGND VGND VPWR VPWR sky130_fd_sc_hd__fill_1
XFILLER_18_155 VGND VGND VPWR VPWR sky130_fd_sc_hd__fill_2
XFILLER_46_464 VGND VGND VPWR VPWR sky130_fd_sc_hd__decap_3
XFILLER_33_103 VGND VGND VPWR VPWR sky130_fd_sc_hd__fill_1
XFILLER_33_158 VGND VGND VPWR VPWR sky130_fd_sc_hd__decap_3
XFILLER_14_361 VGND VGND VPWR VPWR sky130_fd_sc_hd__decap_3
XTAP_TAPCELL_ROW_103_1487 VGND VPWR sky130_fd_sc_hd__tapvpwrvgnd_1
X_3620_ _3620_/A _4292_/B _3620_/C VGND VGND VPWR VPWR _3620_/X sky130_fd_sc_hd__or3_4
X_3551_ _3508_/A _3547_/Y _3550_/X VGND VGND VPWR VPWR _3551_/X sky130_fd_sc_hd__a21o_2
XFILLER_51_3 VGND VGND VPWR VPWR sky130_fd_sc_hd__decap_3
X_6270_ _6553_/A VGND VGND VPWR VPWR _6270_/Y sky130_fd_sc_hd__inv_2
X_3482_ _3482_/A _3482_/B _3482_/C VGND VGND VPWR VPWR _3482_/Y sky130_fd_sc_hd__nor3_2
X_5221_ _7218_/Q _5221_/B VGND VGND VPWR VPWR _7218_/D sky130_fd_sc_hd__and2_2
XTAP_TAPCELL_ROW_71_1100 VGND VPWR sky130_fd_sc_hd__tapvpwrvgnd_1
XFILLER_111_620 VGND VGND VPWR VPWR sky130_fd_sc_hd__decap_3
XFILLER_69_534 VGND VGND VPWR VPWR sky130_fd_sc_hd__fill_1
X_5152_ _7009_/Q _5152_/B VGND VGND VPWR VPWR _5152_/Y sky130_fd_sc_hd__nand2_2
XFILLER_110_130 VGND VGND VPWR VPWR sky130_fd_sc_hd__decap_3
XFILLER_110_141 VGND VGND VPWR VPWR sky130_fd_sc_hd__decap_3
XFILLER_111_653 VGND VGND VPWR VPWR sky130_fd_sc_hd__decap_3
X_4103_ _7365_/Q _4435_/B1 _4352_/B1 _7173_/Q VGND VGND VPWR VPWR _4103_/X sky130_fd_sc_hd__a22o_2
XFILLER_110_174 VGND VGND VPWR VPWR sky130_fd_sc_hd__decap_3
XFILLER_2_71 VGND VGND VPWR VPWR sky130_fd_sc_hd__decap_3
X_5083_ _5086_/A _4343_/X VGND VGND VPWR VPWR _5083_/X sky130_fd_sc_hd__or2b_2
XFILLER_37_431 VGND VGND VPWR VPWR sky130_fd_sc_hd__decap_3
XFILLER_37_442 VGND VGND VPWR VPWR sky130_fd_sc_hd__fill_1
XFILLER_56_239 VGND VGND VPWR VPWR sky130_fd_sc_hd__decap_3
X_4034_ _7150_/Q _4434_/B1 _4032_/X _4033_/X VGND VGND VPWR VPWR _4034_/X sky130_fd_sc_hd__a211o_2
XTAP_TAPCELL_ROW_55_908 VGND VPWR sky130_fd_sc_hd__tapvpwrvgnd_1
XFILLER_112_17 VGND VGND VPWR VPWR sky130_fd_sc_hd__decap_3
XFILLER_24_103 VGND VGND VPWR VPWR sky130_fd_sc_hd__decap_3
XFILLER_64_283 VGND VGND VPWR VPWR sky130_fd_sc_hd__decap_3
XFILLER_92_592 VGND VGND VPWR VPWR sky130_fd_sc_hd__fill_1
XTAP_TAPCELL_ROW_69_1084 VGND VPWR sky130_fd_sc_hd__tapvpwrvgnd_1
XFILLER_12_309 VGND VGND VPWR VPWR sky130_fd_sc_hd__decap_3
XFILLER_52_445 VGND VGND VPWR VPWR sky130_fd_sc_hd__fill_1
XTAP_TAPCELL_ROW_82_1240 VGND VPWR sky130_fd_sc_hd__tapvpwrvgnd_1
XFILLER_33_681 VGND VGND VPWR VPWR sky130_fd_sc_hd__decap_3
X_4936_ _4936_/A _4936_/B VGND VGND VPWR VPWR _4936_/Y sky130_fd_sc_hd__xnor2_2
XTAP_TAPCELL_ROW_35_676 VGND VPWR sky130_fd_sc_hd__tapvpwrvgnd_1
XANTENNA_10 _4365_/A VGND VGND VPWR VPWR sky130_fd_sc_hd__diode_2
X_4867_ _6998_/Q _4912_/A VGND VGND VPWR VPWR _4882_/A sky130_fd_sc_hd__nand2_2
X_6606_ _6606_/A VGND VGND VPWR VPWR _6606_/Y sky130_fd_sc_hd__inv_2
X_3818_ hold981/X _4832_/A _3817_/X VGND VGND VPWR VPWR _7390_/D sky130_fd_sc_hd__o21a_2
XFILLER_20_386 VGND VGND VPWR VPWR sky130_fd_sc_hd__decap_3
X_6537_ _6540_/A VGND VGND VPWR VPWR _6537_/Y sky130_fd_sc_hd__inv_2
X_4798_ _4811_/C _4795_/X _4796_/Y _4797_/X VGND VGND VPWR VPWR _5656_/A sky130_fd_sc_hd__a211o_2
X_3749_ _3726_/X _3734_/X _3748_/X _3896_/B1 VGND VGND VPWR VPWR _3749_/Y sky130_fd_sc_hd__o31ai_2
XFILLER_106_436 VGND VGND VPWR VPWR sky130_fd_sc_hd__decap_3
XFILLER_97_18 VGND VGND VPWR VPWR sky130_fd_sc_hd__decap_3
X_6468_ _6539_/A VGND VGND VPWR VPWR _6468_/Y sky130_fd_sc_hd__inv_2
XFILLER_106_469 VGND VGND VPWR VPWR sky130_fd_sc_hd__decap_3
XFILLER_79_309 VGND VGND VPWR VPWR sky130_fd_sc_hd__decap_3
X_6399_ _6562_/A VGND VGND VPWR VPWR _6399_/Y sky130_fd_sc_hd__inv_2
X_5419_ _5419_/A0 _5131_/X _5423_/S VGND VGND VPWR VPWR _7124_/D sky130_fd_sc_hd__mux2_2
XTAP_TAPCELL_ROW_7_335 VGND VPWR sky130_fd_sc_hd__tapvpwrvgnd_1
XFILLER_102_642 VGND VGND VPWR VPWR sky130_fd_sc_hd__fill_2
XFILLER_87_364 VGND VGND VPWR VPWR sky130_fd_sc_hd__fill_1
XFILLER_102_675 VGND VGND VPWR VPWR sky130_fd_sc_hd__decap_3
XFILLER_47_228 VGND VGND VPWR VPWR sky130_fd_sc_hd__decap_3
XFILLER_87_386 VGND VGND VPWR VPWR sky130_fd_sc_hd__decap_3
XFILLER_46_11 VGND VGND VPWR VPWR sky130_fd_sc_hd__decap_3
XFILLER_28_453 VGND VGND VPWR VPWR sky130_fd_sc_hd__decap_3
XFILLER_15_103 VGND VGND VPWR VPWR sky130_fd_sc_hd__decap_3
XFILLER_46_88 VGND VGND VPWR VPWR sky130_fd_sc_hd__fill_1
XFILLER_102_61 VGND VGND VPWR VPWR sky130_fd_sc_hd__decap_3
XFILLER_15_158 VGND VGND VPWR VPWR sky130_fd_sc_hd__decap_3
XFILLER_62_21 VGND VGND VPWR VPWR sky130_fd_sc_hd__decap_3
XFILLER_70_253 VGND VGND VPWR VPWR sky130_fd_sc_hd__fill_1
XFILLER_102_83 VGND VGND VPWR VPWR sky130_fd_sc_hd__fill_1
XFILLER_102_94 VGND VGND VPWR VPWR sky130_fd_sc_hd__fill_2
XFILLER_30_117 VGND VGND VPWR VPWR sky130_fd_sc_hd__decap_3
XFILLER_11_331 VGND VGND VPWR VPWR sky130_fd_sc_hd__decap_3
XFILLER_62_65 VGND VGND VPWR VPWR sky130_fd_sc_hd__decap_3
XFILLER_11_375 VGND VGND VPWR VPWR sky130_fd_sc_hd__decap_3
XFILLER_7_27 VGND VGND VPWR VPWR sky130_fd_sc_hd__decap_3
XFILLER_7_335 VGND VGND VPWR VPWR sky130_fd_sc_hd__fill_1
XFILLER_7_346 VGND VGND VPWR VPWR sky130_fd_sc_hd__decap_3
XTAP_TAPCELL_ROW_96_1409 VGND VPWR sky130_fd_sc_hd__tapvpwrvgnd_1
XFILLER_109_252 VGND VGND VPWR VPWR sky130_fd_sc_hd__decap_3
XFILLER_3_541 VGND VGND VPWR VPWR sky130_fd_sc_hd__fill_1
XFILLER_97_106 VGND VGND VPWR VPWR sky130_fd_sc_hd__decap_3
XFILLER_98_618 VGND VGND VPWR VPWR sky130_fd_sc_hd__decap_3
XFILLER_105_480 VGND VGND VPWR VPWR sky130_fd_sc_hd__decap_3
XFILLER_3_596 VGND VGND VPWR VPWR sky130_fd_sc_hd__fill_1
XFILLER_97_139 VGND VGND VPWR VPWR sky130_fd_sc_hd__decap_3
XFILLER_78_353 VGND VGND VPWR VPWR sky130_fd_sc_hd__decap_3
XFILLER_87_95 VGND VGND VPWR VPWR sky130_fd_sc_hd__decap_3
XFILLER_16_6 VGND VGND VPWR VPWR sky130_fd_sc_hd__decap_3
XFILLER_19_442 VGND VGND VPWR VPWR sky130_fd_sc_hd__decap_3
XFILLER_93_356 VGND VGND VPWR VPWR sky130_fd_sc_hd__decap_3
XFILLER_61_220 VGND VGND VPWR VPWR sky130_fd_sc_hd__decap_3
XFILLER_74_581 VGND VGND VPWR VPWR sky130_fd_sc_hd__fill_2
XTAP_TAPCELL_ROW_105_1516 VGND VPWR sky130_fd_sc_hd__tapvpwrvgnd_1
XFILLER_15_681 VGND VGND VPWR VPWR sky130_fd_sc_hd__decap_3
XFILLER_61_275 VGND VGND VPWR VPWR sky130_fd_sc_hd__decap_3
XFILLER_99_3 VGND VGND VPWR VPWR sky130_fd_sc_hd__decap_3
XFILLER_14_180 VGND VGND VPWR VPWR sky130_fd_sc_hd__decap_3
X_4721_ _5071_/A _4658_/A _4055_/A VGND VGND VPWR VPWR _4721_/Y sky130_fd_sc_hd__a21oi_2
XTAP_TAPCELL_ROW_60_966 VGND VPWR sky130_fd_sc_hd__tapvpwrvgnd_1
XTAP_TAPCELL_ROW_32_635 VGND VPWR sky130_fd_sc_hd__tapvpwrvgnd_1
X_4652_ _4652_/A _4652_/B VGND VGND VPWR VPWR _4785_/A sky130_fd_sc_hd__nor2_2
XTAP_TAPCELL_ROW_60_977 VGND VPWR sky130_fd_sc_hd__tapvpwrvgnd_1
X_3603_ _4614_/B _3603_/B VGND VGND VPWR VPWR _3603_/Y sky130_fd_sc_hd__nand2_2
X_7371_ _7372_/CLK _7371_/D _6651_/Y VGND VGND VPWR VPWR _7371_/Q sky130_fd_sc_hd__dfrtp_2
Xhold803 _6958_/Q VGND VGND VPWR VPWR _6958_/D sky130_fd_sc_hd__dlygate4sd3_1
X_4583_ _4583_/A _4595_/B VGND VGND VPWR VPWR _7289_/D sky130_fd_sc_hd__and2_2
XTAP_TAPCELL_ROW_12_392 VGND VPWR sky130_fd_sc_hd__tapvpwrvgnd_1
XFILLER_115_211 VGND VGND VPWR VPWR sky130_fd_sc_hd__decap_3
Xhold814 _6830_/Q VGND VGND VPWR VPWR _6830_/D sky130_fd_sc_hd__dlygate4sd3_1
Xhold825 _6735_/Q VGND VGND VPWR VPWR _6735_/D sky130_fd_sc_hd__dlygate4sd3_1
Xhold836 _6765_/Q VGND VGND VPWR VPWR _6765_/D sky130_fd_sc_hd__dlygate4sd3_1
X_6322_ _6644_/A VGND VGND VPWR VPWR _6322_/Y sky130_fd_sc_hd__inv_2
X_3534_ _3509_/Y _3510_/X _4196_/A2 VGND VGND VPWR VPWR _5071_/A sky130_fd_sc_hd__a21oi_2
XTAP_TAPCELL_ROW_116_1656 VGND VPWR sky130_fd_sc_hd__tapvpwrvgnd_1
XTAP_TAPCELL_ROW_116_1645 VGND VPWR sky130_fd_sc_hd__tapvpwrvgnd_1
XFILLER_107_17 VGND VGND VPWR VPWR sky130_fd_sc_hd__decap_3
XFILLER_115_255 VGND VGND VPWR VPWR sky130_fd_sc_hd__decap_3
XFILLER_89_607 VGND VGND VPWR VPWR sky130_fd_sc_hd__fill_1
XFILLER_89_629 VGND VGND VPWR VPWR sky130_fd_sc_hd__decap_3
Xhold847 _7104_/Q VGND VGND VPWR VPWR _7104_/D sky130_fd_sc_hd__dlygate4sd3_1
Xhold858 _7094_/Q VGND VGND VPWR VPWR _7094_/D sky130_fd_sc_hd__dlygate4sd3_1
Xhold869 _7112_/Q VGND VGND VPWR VPWR _7112_/D sky130_fd_sc_hd__dlygate4sd3_1
Xmax_cap566 _4964_/A1 VGND VGND VPWR VPWR _5139_/B1 sky130_fd_sc_hd__clkbuf_2
Xmax_cap555 _5651_/A VGND VGND VPWR VPWR _5660_/C sky130_fd_sc_hd__clkbuf_2
X_3465_ _7185_/Q _3996_/S _4332_/B1 _7377_/Q VGND VGND VPWR VPWR _3465_/X sky130_fd_sc_hd__a22o_2
XFILLER_103_428 VGND VGND VPWR VPWR sky130_fd_sc_hd__fill_2
XFILLER_88_117 VGND VGND VPWR VPWR sky130_fd_sc_hd__decap_3
XTAP_TAPCELL_ROW_4_305 VGND VPWR sky130_fd_sc_hd__tapvpwrvgnd_1
XFILLER_97_662 VGND VGND VPWR VPWR sky130_fd_sc_hd__decap_3
XFILLER_84_312 VGND VGND VPWR VPWR sky130_fd_sc_hd__fill_1
XFILLER_96_150 VGND VGND VPWR VPWR sky130_fd_sc_hd__decap_3
X_5135_ _3371_/A _5666_/A _5581_/S _5134_/X VGND VGND VPWR VPWR _5135_/X sky130_fd_sc_hd__a211o_2
XFILLER_97_673 VGND VGND VPWR VPWR sky130_fd_sc_hd__decap_3
XFILLER_29_228 VGND VGND VPWR VPWR sky130_fd_sc_hd__decap_3
X_5066_ _5066_/A _5066_/B VGND VGND VPWR VPWR _6987_/D sky130_fd_sc_hd__nor2_2
XFILLER_72_529 VGND VGND VPWR VPWR sky130_fd_sc_hd__decap_3
XFILLER_84_356 VGND VGND VPWR VPWR sky130_fd_sc_hd__decap_3
X_4017_ _7310_/Q _4488_/S _4430_/B1 _7182_/Q VGND VGND VPWR VPWR _4017_/X sky130_fd_sc_hd__a22o_2
XFILLER_25_423 VGND VGND VPWR VPWR sky130_fd_sc_hd__decap_3
XFILLER_37_272 VGND VGND VPWR VPWR sky130_fd_sc_hd__decap_3
XFILLER_13_607 VGND VGND VPWR VPWR sky130_fd_sc_hd__decap_3
XFILLER_16_47 VGND VGND VPWR VPWR sky130_fd_sc_hd__decap_3
XFILLER_52_220 VGND VGND VPWR VPWR sky130_fd_sc_hd__decap_3
XFILLER_52_253 VGND VGND VPWR VPWR sky130_fd_sc_hd__decap_3
XFILLER_52_275 VGND VGND VPWR VPWR sky130_fd_sc_hd__decap_3
XFILLER_21_640 VGND VGND VPWR VPWR sky130_fd_sc_hd__fill_1
XFILLER_32_13 VGND VGND VPWR VPWR sky130_fd_sc_hd__decap_3
X_4919_ _4937_/A _4936_/B _4938_/B VGND VGND VPWR VPWR _4920_/B sky130_fd_sc_hd__o21ba_2
XFILLER_20_150 VGND VGND VPWR VPWR sky130_fd_sc_hd__fill_1
XFILLER_4_316 VGND VGND VPWR VPWR sky130_fd_sc_hd__decap_3
XFILLER_106_200 VGND VGND VPWR VPWR sky130_fd_sc_hd__decap_3
XFILLER_106_222 VGND VGND VPWR VPWR sky130_fd_sc_hd__decap_3
XFILLER_106_277 VGND VGND VPWR VPWR sky130_fd_sc_hd__decap_3
XTAP_TAPCELL_ROW_91_1339 VGND VPWR sky130_fd_sc_hd__tapvpwrvgnd_1
XFILLER_0_533 VGND VGND VPWR VPWR sky130_fd_sc_hd__decap_3
XFILLER_88_651 VGND VGND VPWR VPWR sky130_fd_sc_hd__decap_3
XFILLER_0_577 VGND VGND VPWR VPWR sky130_fd_sc_hd__decap_3
XFILLER_102_472 VGND VGND VPWR VPWR sky130_fd_sc_hd__fill_1
XFILLER_57_43 VGND VGND VPWR VPWR sky130_fd_sc_hd__decap_3
XFILLER_87_172 VGND VGND VPWR VPWR sky130_fd_sc_hd__decap_3
XFILLER_75_323 VGND VGND VPWR VPWR sky130_fd_sc_hd__decap_3
XFILLER_63_518 VGND VGND VPWR VPWR sky130_fd_sc_hd__decap_3
XFILLER_75_367 VGND VGND VPWR VPWR sky130_fd_sc_hd__decap_3
XFILLER_90_304 VGND VGND VPWR VPWR sky130_fd_sc_hd__decap_3
XFILLER_113_60 VGND VGND VPWR VPWR sky130_fd_sc_hd__decap_3
XFILLER_16_401 VGND VGND VPWR VPWR sky130_fd_sc_hd__decap_3
XFILLER_28_283 VGND VGND VPWR VPWR sky130_fd_sc_hd__decap_3
XFILLER_56_581 VGND VGND VPWR VPWR sky130_fd_sc_hd__decap_3
XFILLER_56_592 VGND VGND VPWR VPWR sky130_fd_sc_hd__decap_3
XFILLER_113_93 VGND VGND VPWR VPWR sky130_fd_sc_hd__decap_3
XFILLER_31_426 VGND VGND VPWR VPWR sky130_fd_sc_hd__decap_3
XFILLER_71_573 VGND VGND VPWR VPWR sky130_fd_sc_hd__decap_3
XFILLER_71_595 VGND VGND VPWR VPWR sky130_fd_sc_hd__decap_3
XFILLER_73_75 VGND VGND VPWR VPWR sky130_fd_sc_hd__decap_3
XFILLER_12_662 VGND VGND VPWR VPWR sky130_fd_sc_hd__decap_3
XTAP_TAPCELL_ROW_100_1457 VGND VPWR sky130_fd_sc_hd__tapvpwrvgnd_1
XTAP_TAPCELL_ROW_100_1446 VGND VPWR sky130_fd_sc_hd__tapvpwrvgnd_1
XFILLER_11_161 VGND VGND VPWR VPWR sky130_fd_sc_hd__decap_3
XFILLER_11_194 VGND VGND VPWR VPWR sky130_fd_sc_hd__decap_3
XFILLER_7_143 VGND VGND VPWR VPWR sky130_fd_sc_hd__decap_3
XFILLER_8_677 VGND VGND VPWR VPWR sky130_fd_sc_hd__decap_3
XFILLER_98_50 VGND VGND VPWR VPWR sky130_fd_sc_hd__decap_3
XFILLER_112_203 VGND VGND VPWR VPWR sky130_fd_sc_hd__decap_3
XFILLER_98_415 VGND VGND VPWR VPWR sky130_fd_sc_hd__decap_3
XFILLER_112_236 VGND VGND VPWR VPWR sky130_fd_sc_hd__decap_3
XFILLER_3_393 VGND VGND VPWR VPWR sky130_fd_sc_hd__decap_3
XFILLER_98_459 VGND VGND VPWR VPWR sky130_fd_sc_hd__fill_1
XFILLER_79_662 VGND VGND VPWR VPWR sky130_fd_sc_hd__decap_3
XFILLER_79_673 VGND VGND VPWR VPWR sky130_fd_sc_hd__decap_3
XFILLER_85_109 VGND VGND VPWR VPWR sky130_fd_sc_hd__decap_3
XFILLER_94_621 VGND VGND VPWR VPWR sky130_fd_sc_hd__decap_3
XTAP_TAPCELL_ROW_111_1586 VGND VPWR sky130_fd_sc_hd__tapvpwrvgnd_1
XFILLER_14_3 VGND VGND VPWR VPWR sky130_fd_sc_hd__decap_3
XFILLER_39_537 VGND VGND VPWR VPWR sky130_fd_sc_hd__decap_3
XFILLER_94_654 VGND VGND VPWR VPWR sky130_fd_sc_hd__decap_3
XFILLER_26_209 VGND VGND VPWR VPWR sky130_fd_sc_hd__decap_3
XFILLER_66_356 VGND VGND VPWR VPWR sky130_fd_sc_hd__decap_3
XFILLER_66_378 VGND VGND VPWR VPWR sky130_fd_sc_hd__decap_3
XFILLER_94_687 VGND VGND VPWR VPWR sky130_fd_sc_hd__decap_3
X_6940_ _7005_/CLK _6940_/D VGND VGND VPWR VPWR _6940_/Q sky130_fd_sc_hd__dfxtp_2
XFILLER_81_326 VGND VGND VPWR VPWR sky130_fd_sc_hd__decap_3
XFILLER_81_337 VGND VGND VPWR VPWR sky130_fd_sc_hd__fill_1
XFILLER_81_359 VGND VGND VPWR VPWR sky130_fd_sc_hd__decap_3
X_6871_ clkload2/A _6871_/D VGND VGND VPWR VPWR _6871_/Q sky130_fd_sc_hd__dfxtp_2
XTAP_TAPCELL_ROW_66_1043 VGND VPWR sky130_fd_sc_hd__tapvpwrvgnd_1
XFILLER_22_404 VGND VGND VPWR VPWR sky130_fd_sc_hd__fill_1
XFILLER_34_253 VGND VGND VPWR VPWR sky130_fd_sc_hd__fill_1
XTAP_TAPCELL_ROW_17_451 VGND VPWR sky130_fd_sc_hd__tapvpwrvgnd_1
XFILLER_34_286 VGND VGND VPWR VPWR sky130_fd_sc_hd__fill_1
XFILLER_62_595 VGND VGND VPWR VPWR sky130_fd_sc_hd__decap_3
XTAP_TAPCELL_ROW_45_793 VGND VPWR sky130_fd_sc_hd__tapvpwrvgnd_1
X_4704_ _6994_/Q _4977_/A VGND VGND VPWR VPWR _4963_/A sky130_fd_sc_hd__and2_2
X_5684_ _7348_/Q hold961/X _5708_/S VGND VGND VPWR VPWR _6692_/D sky130_fd_sc_hd__mux2_2
X_4635_ _4916_/A _4916_/B _4633_/X _4634_/Y VGND VGND VPWR VPWR _4646_/A sky130_fd_sc_hd__a211o_2
XFILLER_116_531 VGND VGND VPWR VPWR sky130_fd_sc_hd__fill_1
X_7354_ _7387_/CLK _7354_/D _6634_/Y VGND VGND VPWR VPWR _7354_/Q sky130_fd_sc_hd__dfrtp_2
Xhold600 _6919_/Q VGND VGND VPWR VPWR _6919_/D sky130_fd_sc_hd__dlygate4sd3_1
Xhold611 _6856_/Q VGND VGND VPWR VPWR _6856_/D sky130_fd_sc_hd__dlygate4sd3_1
XFILLER_116_542 VGND VGND VPWR VPWR sky130_fd_sc_hd__decap_3
XFILLER_116_564 VGND VGND VPWR VPWR sky130_fd_sc_hd__fill_2
Xhold622 _6805_/Q VGND VGND VPWR VPWR _6805_/D sky130_fd_sc_hd__dlygate4sd3_1
Xhold633 _6815_/Q VGND VGND VPWR VPWR _6815_/D sky130_fd_sc_hd__dlygate4sd3_1
Xhold644 _6882_/Q VGND VGND VPWR VPWR _6882_/D sky130_fd_sc_hd__dlygate4sd3_1
X_6305_ _6647_/A VGND VGND VPWR VPWR _6305_/Y sky130_fd_sc_hd__inv_2
X_3517_ _3386_/B _3370_/Y _3516_/X VGND VGND VPWR VPWR _3525_/A sky130_fd_sc_hd__a21bo_2
XTAP_TAPCELL_ROW_77_1172 VGND VPWR sky130_fd_sc_hd__tapvpwrvgnd_1
XFILLER_103_225 VGND VGND VPWR VPWR sky130_fd_sc_hd__fill_2
XFILLER_116_586 VGND VGND VPWR VPWR sky130_fd_sc_hd__fill_2
XFILLER_1_308 VGND VGND VPWR VPWR sky130_fd_sc_hd__fill_2
X_7285_ clkload3/A _7285_/D _6565_/Y VGND VGND VPWR VPWR _7285_/Q sky130_fd_sc_hd__dfrtp_2
Xhold655 _6845_/Q VGND VGND VPWR VPWR _6845_/D sky130_fd_sc_hd__dlygate4sd3_1
Xhold666 _6941_/Q VGND VGND VPWR VPWR _6941_/D sky130_fd_sc_hd__dlygate4sd3_1
Xhold677 _6800_/Q VGND VGND VPWR VPWR _6800_/D sky130_fd_sc_hd__dlygate4sd3_1
Xhold688 _6858_/Q VGND VGND VPWR VPWR _6858_/D sky130_fd_sc_hd__dlygate4sd3_1
X_4497_ _4497_/A0 _7299_/Q _4501_/S VGND VGND VPWR VPWR _7331_/D sky130_fd_sc_hd__mux2_2
XFILLER_103_247 VGND VGND VPWR VPWR sky130_fd_sc_hd__decap_3
Xhold699 _6719_/Q VGND VGND VPWR VPWR _6719_/D sky130_fd_sc_hd__dlygate4sd3_1
X_3448_ _7282_/Q _5157_/S _4334_/B1 _7154_/Q _3447_/X VGND VGND VPWR VPWR _3448_/X
+ sky130_fd_sc_hd__a221o_2
XFILLER_103_269 VGND VGND VPWR VPWR sky130_fd_sc_hd__decap_3
XFILLER_69_150 VGND VGND VPWR VPWR sky130_fd_sc_hd__decap_3
XFILLER_97_470 VGND VGND VPWR VPWR sky130_fd_sc_hd__decap_3
X_3379_ _7219_/Q _3377_/X _4303_/B1 _7123_/Q VGND VGND VPWR VPWR _3379_/X sky130_fd_sc_hd__a22o_2
XFILLER_57_334 VGND VGND VPWR VPWR sky130_fd_sc_hd__fill_2
XFILLER_69_172 VGND VGND VPWR VPWR sky130_fd_sc_hd__decap_3
XFILLER_84_120 VGND VGND VPWR VPWR sky130_fd_sc_hd__decap_3
XFILLER_85_632 VGND VGND VPWR VPWR sky130_fd_sc_hd__decap_3
X_5118_ _5118_/A _6984_/Q _5118_/C _5118_/D VGND VGND VPWR VPWR _5118_/X sky130_fd_sc_hd__or4_2
XFILLER_27_24 VGND VGND VPWR VPWR sky130_fd_sc_hd__decap_3
XFILLER_57_367 VGND VGND VPWR VPWR sky130_fd_sc_hd__decap_3
XFILLER_72_304 VGND VGND VPWR VPWR sky130_fd_sc_hd__decap_3
XFILLER_84_153 VGND VGND VPWR VPWR sky130_fd_sc_hd__decap_3
XFILLER_85_665 VGND VGND VPWR VPWR sky130_fd_sc_hd__decap_3
XFILLER_85_676 VGND VGND VPWR VPWR sky130_fd_sc_hd__decap_3
XFILLER_27_57 VGND VGND VPWR VPWR sky130_fd_sc_hd__decap_3
XFILLER_72_315 VGND VGND VPWR VPWR sky130_fd_sc_hd__decap_3
XFILLER_84_197 VGND VGND VPWR VPWR sky130_fd_sc_hd__decap_3
X_5049_ _5072_/B _5073_/B _5071_/B VGND VGND VPWR VPWR _5049_/X sky130_fd_sc_hd__a21bo_2
XFILLER_72_348 VGND VGND VPWR VPWR sky130_fd_sc_hd__decap_3
XFILLER_25_264 VGND VGND VPWR VPWR sky130_fd_sc_hd__fill_1
XFILLER_43_12 VGND VGND VPWR VPWR sky130_fd_sc_hd__decap_3
XFILLER_43_45 VGND VGND VPWR VPWR sky130_fd_sc_hd__decap_3
XFILLER_53_595 VGND VGND VPWR VPWR sky130_fd_sc_hd__decap_3
XFILLER_80_392 VGND VGND VPWR VPWR sky130_fd_sc_hd__decap_3
XFILLER_9_408 VGND VGND VPWR VPWR sky130_fd_sc_hd__decap_3
XFILLER_40_256 VGND VGND VPWR VPWR sky130_fd_sc_hd__decap_3
XFILLER_107_520 VGND VGND VPWR VPWR sky130_fd_sc_hd__decap_3
XFILLER_4_124 VGND VGND VPWR VPWR sky130_fd_sc_hd__decap_3
XFILLER_108_71 VGND VGND VPWR VPWR sky130_fd_sc_hd__decap_3
XFILLER_68_20 VGND VGND VPWR VPWR sky130_fd_sc_hd__decap_3
XFILLER_0_330 VGND VGND VPWR VPWR sky130_fd_sc_hd__decap_3
XFILLER_68_64 VGND VGND VPWR VPWR sky130_fd_sc_hd__decap_3
XFILLER_0_385 VGND VGND VPWR VPWR sky130_fd_sc_hd__decap_3
XFILLER_0_396 VGND VGND VPWR VPWR sky130_fd_sc_hd__decap_3
XFILLER_102_280 VGND VGND VPWR VPWR sky130_fd_sc_hd__decap_3
XFILLER_48_312 VGND VGND VPWR VPWR sky130_fd_sc_hd__decap_3
XFILLER_68_97 VGND VGND VPWR VPWR sky130_fd_sc_hd__decap_3
XFILLER_48_345 VGND VGND VPWR VPWR sky130_fd_sc_hd__decap_3
XFILLER_76_654 VGND VGND VPWR VPWR sky130_fd_sc_hd__decap_3
XFILLER_76_687 VGND VGND VPWR VPWR sky130_fd_sc_hd__decap_3
XFILLER_84_41 VGND VGND VPWR VPWR sky130_fd_sc_hd__decap_3
XFILLER_91_602 VGND VGND VPWR VPWR sky130_fd_sc_hd__decap_3
XFILLER_48_389 VGND VGND VPWR VPWR sky130_fd_sc_hd__decap_3
XFILLER_75_175 VGND VGND VPWR VPWR sky130_fd_sc_hd__decap_3
XFILLER_75_197 VGND VGND VPWR VPWR sky130_fd_sc_hd__decap_3
XFILLER_91_635 VGND VGND VPWR VPWR sky130_fd_sc_hd__decap_3
Xplace304 _4765_/A VGND VGND VPWR VPWR _4788_/A sky130_fd_sc_hd__buf_2
XFILLER_84_85 VGND VGND VPWR VPWR sky130_fd_sc_hd__fill_2
XFILLER_84_96 VGND VGND VPWR VPWR sky130_fd_sc_hd__decap_3
XFILLER_90_156 VGND VGND VPWR VPWR sky130_fd_sc_hd__decap_3
XFILLER_91_668 VGND VGND VPWR VPWR sky130_fd_sc_hd__decap_3
XFILLER_91_679 VGND VGND VPWR VPWR sky130_fd_sc_hd__decap_3
Xplace337 _3377_/X VGND VGND VPWR VPWR _4262_/A2 sky130_fd_sc_hd__buf_2
Xplace326 _3590_/A VGND VGND VPWR VPWR _4460_/A sky130_fd_sc_hd__buf_2
Xplace315 _5245_/S VGND VGND VPWR VPWR _5274_/S sky130_fd_sc_hd__buf_2
XFILLER_16_253 VGND VGND VPWR VPWR sky130_fd_sc_hd__decap_3
XFILLER_17_90 VGND VGND VPWR VPWR sky130_fd_sc_hd__decap_3
XFILLER_44_584 VGND VGND VPWR VPWR sky130_fd_sc_hd__decap_3
Xplace359 _3415_/X VGND VGND VPWR VPWR _5136_/S sky130_fd_sc_hd__buf_2
Xplace348 _3449_/X VGND VGND VPWR VPWR _4337_/B sky130_fd_sc_hd__buf_2
XFILLER_31_234 VGND VGND VPWR VPWR sky130_fd_sc_hd__decap_3
XTAP_TAPCELL_ROW_14_421 VGND VPWR sky130_fd_sc_hd__tapvpwrvgnd_1
XTAP_TAPCELL_ROW_42_752 VGND VPWR sky130_fd_sc_hd__tapvpwrvgnd_1
XFILLER_83_6 VGND VGND VPWR VPWR sky130_fd_sc_hd__decap_3
XFILLER_8_430 VGND VGND VPWR VPWR sky130_fd_sc_hd__fill_1
X_4420_ _7336_/Q _3954_/S _4420_/B1 _7144_/Q VGND VGND VPWR VPWR _4420_/X sky130_fd_sc_hd__a22o_2
XTAP_TAPCELL_ROW_113_1604 VGND VPWR sky130_fd_sc_hd__tapvpwrvgnd_1
X_4351_ _7097_/Q _4351_/A2 _4351_/B1 _7129_/Q VGND VGND VPWR VPWR _4351_/X sky130_fd_sc_hd__a22o_2
XFILLER_113_556 VGND VGND VPWR VPWR sky130_fd_sc_hd__decap_3
X_7070_ _7265_/CLK _7070_/D _6350_/Y VGND VGND VPWR VPWR _7070_/Q sky130_fd_sc_hd__dfrtp_2
X_4282_ _7062_/Q _3577_/B _3590_/A _4281_/X VGND VGND VPWR VPWR _4282_/Y sky130_fd_sc_hd__o211ai_2
X_3302_ _3353_/A _6979_/Q _6981_/Q VGND VGND VPWR VPWR _3302_/X sky130_fd_sc_hd__a21o_2
XFILLER_98_256 VGND VGND VPWR VPWR sky130_fd_sc_hd__decap_3
XFILLER_98_234 VGND VGND VPWR VPWR sky130_fd_sc_hd__decap_3
XFILLER_100_206 VGND VGND VPWR VPWR sky130_fd_sc_hd__decap_3
XFILLER_113_567 VGND VGND VPWR VPWR sky130_fd_sc_hd__decap_3
XFILLER_98_278 VGND VGND VPWR VPWR sky130_fd_sc_hd__decap_3
XFILLER_104_18 VGND VGND VPWR VPWR sky130_fd_sc_hd__decap_3
XFILLER_66_120 VGND VGND VPWR VPWR sky130_fd_sc_hd__decap_3
XFILLER_67_632 VGND VGND VPWR VPWR sky130_fd_sc_hd__decap_3
XFILLER_104_29 VGND VGND VPWR VPWR sky130_fd_sc_hd__decap_3
XFILLER_66_153 VGND VGND VPWR VPWR sky130_fd_sc_hd__decap_3
XFILLER_67_665 VGND VGND VPWR VPWR sky130_fd_sc_hd__decap_3
XFILLER_67_676 VGND VGND VPWR VPWR sky130_fd_sc_hd__decap_3
XFILLER_94_462 VGND VGND VPWR VPWR sky130_fd_sc_hd__decap_3
XFILLER_82_613 VGND VGND VPWR VPWR sky130_fd_sc_hd__decap_3
XFILLER_54_359 VGND VGND VPWR VPWR sky130_fd_sc_hd__decap_3
XFILLER_66_197 VGND VGND VPWR VPWR sky130_fd_sc_hd__decap_3
XFILLER_81_134 VGND VGND VPWR VPWR sky130_fd_sc_hd__fill_1
XFILLER_82_657 VGND VGND VPWR VPWR sky130_fd_sc_hd__decap_3
X_6923_ _7392_/CLK _6923_/D VGND VGND VPWR VPWR _6923_/Q sky130_fd_sc_hd__dfxtp_2
XFILLER_81_178 VGND VGND VPWR VPWR sky130_fd_sc_hd__decap_3
XFILLER_22_223 VGND VGND VPWR VPWR sky130_fd_sc_hd__decap_3
XFILLER_35_595 VGND VGND VPWR VPWR sky130_fd_sc_hd__fill_1
XFILLER_90_690 VGND VGND VPWR VPWR sky130_fd_sc_hd__fill_2
Xfanout16 _6347_/A VGND VGND VPWR VPWR _6568_/A sky130_fd_sc_hd__buf_2
Xfanout27 _6664_/A VGND VGND VPWR VPWR _6634_/A sky130_fd_sc_hd__buf_2
Xfanout38 _6536_/A VGND VGND VPWR VPWR fanout38/X sky130_fd_sc_hd__clkdlybuf4s25_1
X_6854_ _6971_/CLK _6854_/D VGND VGND VPWR VPWR _6854_/Q sky130_fd_sc_hd__dfxtp_2
XFILLER_22_267 VGND VGND VPWR VPWR sky130_fd_sc_hd__decap_3
XFILLER_50_565 VGND VGND VPWR VPWR sky130_fd_sc_hd__decap_3
Xfanout49 fanout51/X VGND VGND VPWR VPWR _6366_/A sky130_fd_sc_hd__buf_2
X_6785_ clkload2/A _6785_/D VGND VGND VPWR VPWR _6785_/Q sky130_fd_sc_hd__dfxtp_2
XFILLER_13_26 VGND VGND VPWR VPWR sky130_fd_sc_hd__decap_3
X_5667_ _5667_/A _5668_/B VGND VGND VPWR VPWR _6979_/D sky130_fd_sc_hd__nor2_2
XTAP_TAPCELL_ROW_79_1201 VGND VPWR sky130_fd_sc_hd__tapvpwrvgnd_1
X_7406_ _7406_/CLK _7406_/D _6686_/Y VGND VGND VPWR VPWR _7406_/Q sky130_fd_sc_hd__dfrtp_2
X_5598_ hold941/X _5598_/A2 _4468_/X VGND VGND VPWR VPWR _7028_/D sky130_fd_sc_hd__a21o_2
XFILLER_116_350 VGND VGND VPWR VPWR sky130_fd_sc_hd__decap_3
XFILLER_1_105 VGND VGND VPWR VPWR sky130_fd_sc_hd__decap_3
XFILLER_1_116 VGND VGND VPWR VPWR sky130_fd_sc_hd__decap_3
XFILLER_2_639 VGND VGND VPWR VPWR sky130_fd_sc_hd__decap_3
X_7337_ _7337_/CLK _7337_/D _6617_/Y VGND VGND VPWR VPWR _7337_/Q sky130_fd_sc_hd__dfrtp_2
XFILLER_1_149 VGND VGND VPWR VPWR sky130_fd_sc_hd__decap_3
XFILLER_89_223 VGND VGND VPWR VPWR sky130_fd_sc_hd__fill_1
XFILLER_89_234 VGND VGND VPWR VPWR sky130_fd_sc_hd__decap_3
X_7268_ _7397_/CLK _7268_/D _6548_/Y VGND VGND VPWR VPWR _7268_/Q sky130_fd_sc_hd__dfrtp_2
XFILLER_38_12 VGND VGND VPWR VPWR sky130_fd_sc_hd__decap_3
XFILLER_58_610 VGND VGND VPWR VPWR sky130_fd_sc_hd__decap_3
XFILLER_77_429 VGND VGND VPWR VPWR sky130_fd_sc_hd__decap_3
XFILLER_58_643 VGND VGND VPWR VPWR sky130_fd_sc_hd__fill_1
X_7199_ _7364_/CLK _7199_/D _6479_/Y VGND VGND VPWR VPWR _7199_/Q sky130_fd_sc_hd__dfrtp_2
XFILLER_57_153 VGND VGND VPWR VPWR sky130_fd_sc_hd__decap_3
XFILLER_58_654 VGND VGND VPWR VPWR sky130_fd_sc_hd__decap_3
Xhold1130 _7161_/Q VGND VGND VPWR VPWR _5340_/A0 sky130_fd_sc_hd__dlygate4sd3_1
Xhold1141 _7174_/Q VGND VGND VPWR VPWR _5312_/A0 sky130_fd_sc_hd__dlygate4sd3_1
XFILLER_73_635 VGND VGND VPWR VPWR sky130_fd_sc_hd__decap_3
Xhold1152 _7296_/Q VGND VGND VPWR VPWR _4569_/A sky130_fd_sc_hd__dlygate4sd3_1
Xhold1163 _7120_/Q VGND VGND VPWR VPWR _5427_/A0 sky130_fd_sc_hd__dlygate4sd3_1
Xhold1174 _7134_/Q VGND VGND VPWR VPWR _5398_/A0 sky130_fd_sc_hd__dlygate4sd3_1
Xhold1185 _7131_/Q VGND VGND VPWR VPWR _5404_/A0 sky130_fd_sc_hd__dlygate4sd3_1
XFILLER_72_145 VGND VGND VPWR VPWR sky130_fd_sc_hd__decap_3
XFILLER_73_668 VGND VGND VPWR VPWR sky130_fd_sc_hd__decap_3
XFILLER_73_679 VGND VGND VPWR VPWR sky130_fd_sc_hd__decap_3
Xhold1196 _7155_/Q VGND VGND VPWR VPWR _5352_/A0 sky130_fd_sc_hd__dlygate4sd3_1
XFILLER_54_77 VGND VGND VPWR VPWR sky130_fd_sc_hd__decap_3
XFILLER_54_88 VGND VGND VPWR VPWR sky130_fd_sc_hd__decap_3
XFILLER_110_50 VGND VGND VPWR VPWR sky130_fd_sc_hd__decap_3
XFILLER_9_205 VGND VGND VPWR VPWR sky130_fd_sc_hd__fill_1
XFILLER_110_83 VGND VGND VPWR VPWR sky130_fd_sc_hd__fill_1
XFILLER_110_94 VGND VGND VPWR VPWR sky130_fd_sc_hd__decap_3
XFILLER_70_21 VGND VGND VPWR VPWR sky130_fd_sc_hd__decap_3
XFILLER_70_43 VGND VGND VPWR VPWR sky130_fd_sc_hd__decap_3
XFILLER_9_249 VGND VGND VPWR VPWR sky130_fd_sc_hd__fill_1
XFILLER_70_76 VGND VGND VPWR VPWR sky130_fd_sc_hd__fill_1
XFILLER_5_411 VGND VGND VPWR VPWR sky130_fd_sc_hd__decap_3
Xclkload19 _6976_/CLK VGND VGND VPWR VPWR clkload19/X sky130_fd_sc_hd__clkbuf_1
XFILLER_114_309 VGND VGND VPWR VPWR sky130_fd_sc_hd__decap_3
XFILLER_5_444 VGND VGND VPWR VPWR sky130_fd_sc_hd__decap_3
XFILLER_5_455 VGND VGND VPWR VPWR sky130_fd_sc_hd__decap_3
XFILLER_79_41 VGND VGND VPWR VPWR sky130_fd_sc_hd__decap_3
XFILLER_79_63 VGND VGND VPWR VPWR sky130_fd_sc_hd__decap_3
XFILLER_48_9 VGND VGND VPWR VPWR sky130_fd_sc_hd__decap_3
XFILLER_79_96 VGND VGND VPWR VPWR sky130_fd_sc_hd__decap_3
XFILLER_1_661 VGND VGND VPWR VPWR sky130_fd_sc_hd__decap_3
XFILLER_110_548 VGND VGND VPWR VPWR sky130_fd_sc_hd__decap_3
XFILLER_49_632 VGND VGND VPWR VPWR sky130_fd_sc_hd__decap_3
XFILLER_95_237 VGND VGND VPWR VPWR sky130_fd_sc_hd__decap_3
XFILLER_95_40 VGND VGND VPWR VPWR sky130_fd_sc_hd__decap_3
XFILLER_48_120 VGND VGND VPWR VPWR sky130_fd_sc_hd__decap_3
XFILLER_49_665 VGND VGND VPWR VPWR sky130_fd_sc_hd__decap_3
XFILLER_49_676 VGND VGND VPWR VPWR sky130_fd_sc_hd__decap_3
XFILLER_76_451 VGND VGND VPWR VPWR sky130_fd_sc_hd__decap_3
XFILLER_36_304 VGND VGND VPWR VPWR sky130_fd_sc_hd__decap_3
XFILLER_36_326 VGND VGND VPWR VPWR sky130_fd_sc_hd__decap_3
XFILLER_48_186 VGND VGND VPWR VPWR sky130_fd_sc_hd__decap_3
XFILLER_64_613 VGND VGND VPWR VPWR sky130_fd_sc_hd__decap_3
XFILLER_95_95 VGND VGND VPWR VPWR sky130_fd_sc_hd__decap_3
XTAP_TAPCELL_ROW_47_811 VGND VPWR sky130_fd_sc_hd__tapvpwrvgnd_1
XFILLER_36_359 VGND VGND VPWR VPWR sky130_fd_sc_hd__decap_3
XFILLER_48_197 VGND VGND VPWR VPWR sky130_fd_sc_hd__decap_3
XFILLER_63_134 VGND VGND VPWR VPWR sky130_fd_sc_hd__fill_1
XFILLER_64_657 VGND VGND VPWR VPWR sky130_fd_sc_hd__decap_3
XFILLER_17_573 VGND VGND VPWR VPWR sky130_fd_sc_hd__decap_3
XFILLER_63_167 VGND VGND VPWR VPWR sky130_fd_sc_hd__fill_1
X_3920_ hold991/X _5151_/A _3919_/X VGND VGND VPWR VPWR _7377_/D sky130_fd_sc_hd__o21a_2
XFILLER_32_521 VGND VGND VPWR VPWR sky130_fd_sc_hd__decap_3
XFILLER_72_690 VGND VGND VPWR VPWR sky130_fd_sc_hd__fill_2
XTAP_TAPCELL_ROW_63_1013 VGND VPWR sky130_fd_sc_hd__tapvpwrvgnd_1
XTAP_TAPCELL_ROW_63_1002 VGND VPWR sky130_fd_sc_hd__tapvpwrvgnd_1
X_3851_ _6825_/Q _3906_/A2 _3886_/B1 _6815_/Q _3850_/X VGND VGND VPWR VPWR _3851_/X
+ sky130_fd_sc_hd__a221o_2
XFILLER_81_3 VGND VGND VPWR VPWR sky130_fd_sc_hd__decap_3
X_6570_ _6570_/A VGND VGND VPWR VPWR _6570_/Y sky130_fd_sc_hd__inv_2
X_3782_ _6827_/Q _3886_/A2 _3886_/B1 _6817_/Q VGND VGND VPWR VPWR _3782_/X sky130_fd_sc_hd__a22o_2
Xoutput502 _5641_/Y VGND VGND VPWR VPWR instruction_out[17] sky130_fd_sc_hd__clkdlybuf4s25_1
Xoutput535 _6998_/Q VGND VGND VPWR VPWR pc_out[21] sky130_fd_sc_hd__clkdlybuf4s25_1
Xoutput524 _6988_/Q VGND VGND VPWR VPWR pc_out[11] sky130_fd_sc_hd__clkdlybuf4s25_1
Xoutput513 _3509_/B VGND VGND VPWR VPWR instruction_out[2] sky130_fd_sc_hd__clkdlybuf4s25_1
X_5383_ _7141_/Q _4878_/X _5396_/S VGND VGND VPWR VPWR _7141_/D sky130_fd_sc_hd__mux2_2
X_4403_ _4403_/A VGND VGND VPWR VPWR _4411_/A sky130_fd_sc_hd__inv_2
XFILLER_99_521 VGND VGND VPWR VPWR sky130_fd_sc_hd__decap_3
XFILLER_5_60 VGND VGND VPWR VPWR sky130_fd_sc_hd__decap_3
X_7122_ _7352_/CLK _7122_/D _6402_/Y VGND VGND VPWR VPWR _7122_/Q sky130_fd_sc_hd__dfrtp_2
Xoutput546 _7008_/Q VGND VGND VPWR VPWR pc_out[31] sky130_fd_sc_hd__clkdlybuf4s25_1
X_4334_ _7351_/Q _3449_/X _4334_/B1 _7159_/Q VGND VGND VPWR VPWR _4336_/B sky130_fd_sc_hd__a22o_2
XTAP_TAPCELL_ROW_74_1142 VGND VPWR sky130_fd_sc_hd__tapvpwrvgnd_1
XFILLER_5_93 VGND VGND VPWR VPWR sky130_fd_sc_hd__decap_3
X_7053_ _7374_/CLK _7053_/D _6333_/Y VGND VGND VPWR VPWR _7053_/Q sky130_fd_sc_hd__dfrtp_2
XFILLER_101_537 VGND VGND VPWR VPWR sky130_fd_sc_hd__decap_3
XFILLER_101_548 VGND VGND VPWR VPWR sky130_fd_sc_hd__fill_2
XFILLER_113_386 VGND VGND VPWR VPWR sky130_fd_sc_hd__decap_3
XFILLER_86_215 VGND VGND VPWR VPWR sky130_fd_sc_hd__decap_3
X_4265_ _7070_/Q _4265_/B VGND VGND VPWR VPWR _4376_/C sky130_fd_sc_hd__nor2_2
XFILLER_101_559 VGND VGND VPWR VPWR sky130_fd_sc_hd__fill_1
XFILLER_86_259 VGND VGND VPWR VPWR sky130_fd_sc_hd__decap_3
X_4196_ _7391_/Q _4196_/A2 _5028_/S _7295_/Q _4195_/X VGND VGND VPWR VPWR _4196_/X
+ sky130_fd_sc_hd__a221o_2
XFILLER_39_175 VGND VGND VPWR VPWR sky130_fd_sc_hd__decap_3
XFILLER_55_635 VGND VGND VPWR VPWR sky130_fd_sc_hd__decap_3
XFILLER_67_484 VGND VGND VPWR VPWR sky130_fd_sc_hd__decap_3
XFILLER_39_197 VGND VGND VPWR VPWR sky130_fd_sc_hd__decap_3
XFILLER_54_112 VGND VGND VPWR VPWR sky130_fd_sc_hd__decap_3
XFILLER_55_668 VGND VGND VPWR VPWR sky130_fd_sc_hd__decap_3
XFILLER_82_421 VGND VGND VPWR VPWR sky130_fd_sc_hd__decap_3
XFILLER_94_292 VGND VGND VPWR VPWR sky130_fd_sc_hd__decap_3
XFILLER_54_156 VGND VGND VPWR VPWR sky130_fd_sc_hd__fill_2
XFILLER_55_679 VGND VGND VPWR VPWR sky130_fd_sc_hd__decap_3
XFILLER_70_616 VGND VGND VPWR VPWR sky130_fd_sc_hd__decap_3
XFILLER_24_14 VGND VGND VPWR VPWR sky130_fd_sc_hd__decap_3
XFILLER_35_370 VGND VGND VPWR VPWR sky130_fd_sc_hd__decap_3
XFILLER_35_381 VGND VGND VPWR VPWR sky130_fd_sc_hd__decap_3
XFILLER_54_189 VGND VGND VPWR VPWR sky130_fd_sc_hd__decap_3
X_6906_ _6909_/CLK _6906_/D VGND VGND VPWR VPWR _6906_/Q sky130_fd_sc_hd__dfxtp_2
XTAP_TAPCELL_ROW_85_1271 VGND VPWR sky130_fd_sc_hd__tapvpwrvgnd_1
XTAP_TAPCELL_ROW_25_549 VGND VPWR sky130_fd_sc_hd__tapvpwrvgnd_1
X_6837_ _6972_/CLK _6837_/D VGND VGND VPWR VPWR _6837_/Q sky130_fd_sc_hd__dfxtp_2
XFILLER_10_215 VGND VGND VPWR VPWR sky130_fd_sc_hd__decap_3
XFILLER_109_615 VGND VGND VPWR VPWR sky130_fd_sc_hd__fill_1
XFILLER_10_259 VGND VGND VPWR VPWR sky130_fd_sc_hd__decap_3
X_6768_ _6971_/CLK _6768_/D VGND VGND VPWR VPWR _6768_/Q sky130_fd_sc_hd__dfxtp_2
XFILLER_108_103 VGND VGND VPWR VPWR sky130_fd_sc_hd__decap_3
XFILLER_109_626 VGND VGND VPWR VPWR sky130_fd_sc_hd__decap_3
XFILLER_40_24 VGND VGND VPWR VPWR sky130_fd_sc_hd__decap_3
X_6699_ _7384_/CLK _6699_/D VGND VGND VPWR VPWR _6699_/Q sky130_fd_sc_hd__dfxtp_2
X_5719_ _7365_/Q hold926/X _5721_/S VGND VGND VPWR VPWR _6709_/D sky130_fd_sc_hd__mux2_2
XFILLER_108_136 VGND VGND VPWR VPWR sky130_fd_sc_hd__decap_3
XFILLER_108_147 VGND VGND VPWR VPWR sky130_fd_sc_hd__decap_3
XFILLER_109_659 VGND VGND VPWR VPWR sky130_fd_sc_hd__decap_3
XFILLER_40_57 VGND VGND VPWR VPWR sky130_fd_sc_hd__decap_3
XFILLER_2_436 VGND VGND VPWR VPWR sky130_fd_sc_hd__decap_3
XFILLER_104_342 VGND VGND VPWR VPWR sky130_fd_sc_hd__fill_2
XFILLER_2_469 VGND VGND VPWR VPWR sky130_fd_sc_hd__decap_3
XFILLER_1_29 VGND VGND VPWR VPWR sky130_fd_sc_hd__decap_3
XFILLER_49_99 VGND VGND VPWR VPWR sky130_fd_sc_hd__decap_3
XFILLER_77_248 VGND VGND VPWR VPWR sky130_fd_sc_hd__decap_3
XFILLER_105_72 VGND VGND VPWR VPWR sky130_fd_sc_hd__decap_3
XFILLER_46_635 VGND VGND VPWR VPWR sky130_fd_sc_hd__decap_3
XFILLER_65_21 VGND VGND VPWR VPWR sky130_fd_sc_hd__fill_2
XFILLER_92_207 VGND VGND VPWR VPWR sky130_fd_sc_hd__decap_3
XFILLER_92_218 VGND VGND VPWR VPWR sky130_fd_sc_hd__decap_3
XFILLER_46_657 VGND VGND VPWR VPWR sky130_fd_sc_hd__decap_3
XFILLER_73_432 VGND VGND VPWR VPWR sky130_fd_sc_hd__decap_3
XFILLER_85_281 VGND VGND VPWR VPWR sky130_fd_sc_hd__fill_1
XFILLER_45_178 VGND VGND VPWR VPWR sky130_fd_sc_hd__decap_3
XFILLER_61_605 VGND VGND VPWR VPWR sky130_fd_sc_hd__decap_3
XFILLER_65_87 VGND VGND VPWR VPWR sky130_fd_sc_hd__decap_3
XFILLER_73_465 VGND VGND VPWR VPWR sky130_fd_sc_hd__fill_1
XFILLER_14_510 VGND VGND VPWR VPWR sky130_fd_sc_hd__decap_3
XFILLER_33_329 VGND VGND VPWR VPWR sky130_fd_sc_hd__decap_3
XFILLER_54_690 VGND VGND VPWR VPWR sky130_fd_sc_hd__fill_2
XFILLER_60_126 VGND VGND VPWR VPWR sky130_fd_sc_hd__decap_3
XFILLER_61_638 VGND VGND VPWR VPWR sky130_fd_sc_hd__decap_3
XFILLER_60_148 VGND VGND VPWR VPWR sky130_fd_sc_hd__decap_3
XFILLER_60_159 VGND VGND VPWR VPWR sky130_fd_sc_hd__decap_3
XFILLER_81_42 VGND VGND VPWR VPWR sky130_fd_sc_hd__decap_3
XFILLER_14_587 VGND VGND VPWR VPWR sky130_fd_sc_hd__fill_1
XFILLER_41_384 VGND VGND VPWR VPWR sky130_fd_sc_hd__fill_1
XTAP_TAPCELL_ROW_52_880 VGND VPWR sky130_fd_sc_hd__tapvpwrvgnd_1
XFILLER_14_80 VGND VGND VPWR VPWR sky130_fd_sc_hd__fill_1
XFILLER_108_681 VGND VGND VPWR VPWR sky130_fd_sc_hd__decap_3
XFILLER_114_106 VGND VGND VPWR VPWR sky130_fd_sc_hd__decap_3
XFILLER_115_629 VGND VGND VPWR VPWR sky130_fd_sc_hd__decap_3
XFILLER_5_252 VGND VGND VPWR VPWR sky130_fd_sc_hd__fill_1
XFILLER_114_139 VGND VGND VPWR VPWR sky130_fd_sc_hd__fill_1
XFILLER_5_274 VGND VGND VPWR VPWR sky130_fd_sc_hd__decap_3
XFILLER_49_440 VGND VGND VPWR VPWR sky130_fd_sc_hd__decap_3
XFILLER_68_248 VGND VGND VPWR VPWR sky130_fd_sc_hd__fill_1
X_4050_ _7053_/Q _4482_/S _4437_/B1 _7405_/Q _4049_/X VGND VGND VPWR VPWR _4050_/X
+ sky130_fd_sc_hd__a221o_2
XFILLER_36_101 VGND VGND VPWR VPWR sky130_fd_sc_hd__decap_3
XFILLER_76_270 VGND VGND VPWR VPWR sky130_fd_sc_hd__decap_3
XFILLER_36_134 VGND VGND VPWR VPWR sky130_fd_sc_hd__decap_3
XFILLER_49_495 VGND VGND VPWR VPWR sky130_fd_sc_hd__decap_3
XFILLER_64_421 VGND VGND VPWR VPWR sky130_fd_sc_hd__fill_2
XFILLER_64_432 VGND VGND VPWR VPWR sky130_fd_sc_hd__decap_3
XTAP_TAPCELL_ROW_108_1547 VGND VPWR sky130_fd_sc_hd__tapvpwrvgnd_1
XFILLER_36_167 VGND VGND VPWR VPWR sky130_fd_sc_hd__decap_3
XFILLER_36_178 VGND VGND VPWR VPWR sky130_fd_sc_hd__decap_3
XFILLER_37_679 VGND VGND VPWR VPWR sky130_fd_sc_hd__decap_3
XFILLER_52_616 VGND VGND VPWR VPWR sky130_fd_sc_hd__decap_3
XFILLER_91_251 VGND VGND VPWR VPWR sky130_fd_sc_hd__fill_2
XFILLER_91_262 VGND VGND VPWR VPWR sky130_fd_sc_hd__decap_3
XFILLER_91_295 VGND VGND VPWR VPWR sky130_fd_sc_hd__decap_3
X_4952_ _4967_/B _4968_/A VGND VGND VPWR VPWR _4969_/C sky130_fd_sc_hd__or2b_2
XFILLER_51_148 VGND VGND VPWR VPWR sky130_fd_sc_hd__decap_3
XFILLER_60_660 VGND VGND VPWR VPWR sky130_fd_sc_hd__decap_3
X_3903_ _6782_/Q _3926_/B1 _5660_/B _6692_/Q _3902_/X VGND VGND VPWR VPWR _3904_/B
+ sky130_fd_sc_hd__a221o_2
XFILLER_20_502 VGND VGND VPWR VPWR sky130_fd_sc_hd__decap_3
XFILLER_32_373 VGND VGND VPWR VPWR sky130_fd_sc_hd__fill_2
X_6622_ _6683_/A VGND VGND VPWR VPWR _6622_/Y sky130_fd_sc_hd__inv_2
XTAP_TAPCELL_ROW_22_519 VGND VPWR sky130_fd_sc_hd__tapvpwrvgnd_1
XFILLER_32_395 VGND VGND VPWR VPWR sky130_fd_sc_hd__decap_3
X_6553_ _6553_/A VGND VGND VPWR VPWR _6553_/Y sky130_fd_sc_hd__inv_2
X_3765_ _3629_/Y _3764_/X _4799_/A VGND VGND VPWR VPWR _4927_/B sky130_fd_sc_hd__o21a_2
X_6484_ _6642_/A VGND VGND VPWR VPWR _6484_/Y sky130_fd_sc_hd__inv_2
X_3696_ _6940_/Q _3768_/A2 _3759_/A2 _6804_/Q _3695_/X VGND VGND VPWR VPWR _3696_/X
+ sky130_fd_sc_hd__a221o_2
XFILLER_106_618 VGND VGND VPWR VPWR sky130_fd_sc_hd__decap_3
XFILLER_10_27 VGND VGND VPWR VPWR sky130_fd_sc_hd__fill_1
XFILLER_105_128 VGND VGND VPWR VPWR sky130_fd_sc_hd__decap_3
XFILLER_10_38 VGND VGND VPWR VPWR sky130_fd_sc_hd__decap_3
XFILLER_114_640 VGND VGND VPWR VPWR sky130_fd_sc_hd__decap_3
XFILLER_114_651 VGND VGND VPWR VPWR sky130_fd_sc_hd__decap_3
XFILLER_113_161 VGND VGND VPWR VPWR sky130_fd_sc_hd__decap_3
XFILLER_113_172 VGND VGND VPWR VPWR sky130_fd_sc_hd__decap_3
XFILLER_114_684 VGND VGND VPWR VPWR sky130_fd_sc_hd__decap_3
XFILLER_59_215 VGND VGND VPWR VPWR sky130_fd_sc_hd__decap_3
XFILLER_87_513 VGND VGND VPWR VPWR sky130_fd_sc_hd__decap_3
X_7105_ _7265_/CLK _7105_/D _6385_/Y VGND VGND VPWR VPWR _7105_/Q sky130_fd_sc_hd__dfrtp_2
X_4317_ _7322_/Q _4471_/S _3380_/Y _7354_/Q _4347_/C1 VGND VGND VPWR VPWR _4317_/X
+ sky130_fd_sc_hd__a221o_2
XFILLER_99_384 VGND VGND VPWR VPWR sky130_fd_sc_hd__decap_3
XFILLER_101_334 VGND VGND VPWR VPWR sky130_fd_sc_hd__fill_2
XFILLER_19_14 VGND VGND VPWR VPWR sky130_fd_sc_hd__decap_3
XFILLER_19_47 VGND VGND VPWR VPWR sky130_fd_sc_hd__fill_2
XFILLER_59_259 VGND VGND VPWR VPWR sky130_fd_sc_hd__decap_3
X_7036_ _7387_/CLK _7036_/D _6316_/Y VGND VGND VPWR VPWR _7036_/Q sky130_fd_sc_hd__dfrtp_2
X_4248_ _4248_/A _4248_/B _4248_/C VGND VGND VPWR VPWR _4626_/B sky130_fd_sc_hd__or3_4
XFILLER_67_270 VGND VGND VPWR VPWR sky130_fd_sc_hd__fill_1
XFILLER_74_229 VGND VGND VPWR VPWR sky130_fd_sc_hd__decap_3
XTAP_TAPCELL_ROW_87_1300 VGND VPWR sky130_fd_sc_hd__tapvpwrvgnd_1
XFILLER_27_134 VGND VGND VPWR VPWR sky130_fd_sc_hd__decap_3
XFILLER_67_281 VGND VGND VPWR VPWR sky130_fd_sc_hd__fill_2
X_4179_ _4173_/Y _3388_/Y _4376_/A _4178_/Y VGND VGND VPWR VPWR _4186_/A sky130_fd_sc_hd__a211o_2
XFILLER_82_251 VGND VGND VPWR VPWR sky130_fd_sc_hd__fill_1
XFILLER_82_262 VGND VGND VPWR VPWR sky130_fd_sc_hd__decap_3
XTAP_TAPCELL_ROW_2_277 VGND VPWR sky130_fd_sc_hd__tapvpwrvgnd_1
XFILLER_15_329 VGND VGND VPWR VPWR sky130_fd_sc_hd__decap_3
XFILLER_35_46 VGND VGND VPWR VPWR sky130_fd_sc_hd__fill_1
XFILLER_35_57 VGND VGND VPWR VPWR sky130_fd_sc_hd__fill_1
XFILLER_42_115 VGND VGND VPWR VPWR sky130_fd_sc_hd__decap_3
XFILLER_70_424 VGND VGND VPWR VPWR sky130_fd_sc_hd__decap_3
XFILLER_23_340 VGND VGND VPWR VPWR sky130_fd_sc_hd__fill_1
XFILLER_35_68 VGND VGND VPWR VPWR sky130_fd_sc_hd__decap_3
XFILLER_70_468 VGND VGND VPWR VPWR sky130_fd_sc_hd__decap_3
XFILLER_11_502 VGND VGND VPWR VPWR sky130_fd_sc_hd__fill_2
XFILLER_23_362 VGND VGND VPWR VPWR sky130_fd_sc_hd__decap_3
XFILLER_51_12 VGND VGND VPWR VPWR sky130_fd_sc_hd__decap_3
XFILLER_51_671 VGND VGND VPWR VPWR sky130_fd_sc_hd__fill_1
XFILLER_51_682 VGND VGND VPWR VPWR sky130_fd_sc_hd__decap_3
XFILLER_51_45 VGND VGND VPWR VPWR sky130_fd_sc_hd__fill_1
Xclkbuf_3_3__f_clk clkbuf_0_clk/X VGND VGND VPWR VPWR clkload0/A sky130_fd_sc_hd__clkbuf_16
XPHY_EDGE_ROW_14_Right_14 VGND VGND VPWR VPWR sky130_fd_sc_hd__decap_3
XFILLER_11_568 VGND VGND VPWR VPWR sky130_fd_sc_hd__decap_3
XFILLER_51_78 VGND VGND VPWR VPWR sky130_fd_sc_hd__decap_3
XFILLER_109_489 VGND VGND VPWR VPWR sky130_fd_sc_hd__decap_3
XFILLER_2_200 VGND VGND VPWR VPWR sky130_fd_sc_hd__decap_3
XFILLER_105_662 VGND VGND VPWR VPWR sky130_fd_sc_hd__decap_3
XFILLER_105_673 VGND VGND VPWR VPWR sky130_fd_sc_hd__decap_3
XFILLER_104_150 VGND VGND VPWR VPWR sky130_fd_sc_hd__decap_3
XFILLER_78_524 VGND VGND VPWR VPWR sky130_fd_sc_hd__decap_3
XPHY_EDGE_ROW_23_Right_23 VGND VGND VPWR VPWR sky130_fd_sc_hd__decap_3
XFILLER_116_71 VGND VGND VPWR VPWR sky130_fd_sc_hd__decap_3
XFILLER_93_505 VGND VGND VPWR VPWR sky130_fd_sc_hd__decap_3
XFILLER_76_53 VGND VGND VPWR VPWR sky130_fd_sc_hd__decap_3
XFILLER_93_538 VGND VGND VPWR VPWR sky130_fd_sc_hd__decap_3
XFILLER_46_421 VGND VGND VPWR VPWR sky130_fd_sc_hd__decap_3
XFILLER_46_443 VGND VGND VPWR VPWR sky130_fd_sc_hd__decap_3
XFILLER_61_402 VGND VGND VPWR VPWR sky130_fd_sc_hd__decap_3
XFILLER_73_251 VGND VGND VPWR VPWR sky130_fd_sc_hd__decap_3
Xplace74 _5656_/C VGND VGND VPWR VPWR place74/X sky130_fd_sc_hd__buf_2
XFILLER_18_189 VGND VGND VPWR VPWR sky130_fd_sc_hd__decap_3
XFILLER_46_487 VGND VGND VPWR VPWR sky130_fd_sc_hd__decap_3
XFILLER_73_284 VGND VGND VPWR VPWR sky130_fd_sc_hd__decap_3
XFILLER_92_41 VGND VGND VPWR VPWR sky130_fd_sc_hd__decap_3
XFILLER_92_63 VGND VGND VPWR VPWR sky130_fd_sc_hd__decap_3
XFILLER_92_85 VGND VGND VPWR VPWR sky130_fd_sc_hd__decap_3
XPHY_EDGE_ROW_32_Right_32 VGND VGND VPWR VPWR sky130_fd_sc_hd__decap_3
XFILLER_14_351 VGND VGND VPWR VPWR sky130_fd_sc_hd__fill_2
XFILLER_42_671 VGND VGND VPWR VPWR sky130_fd_sc_hd__decap_3
XFILLER_41_192 VGND VGND VPWR VPWR sky130_fd_sc_hd__fill_2
XTAP_TAPCELL_ROW_103_1488 VGND VPWR sky130_fd_sc_hd__tapvpwrvgnd_1
X_3550_ _4614_/A _3547_/A _3547_/B _3548_/X VGND VGND VPWR VPWR _3550_/X sky130_fd_sc_hd__a31o_2
XFILLER_6_550 VGND VGND VPWR VPWR sky130_fd_sc_hd__fill_1
X_3481_ _7344_/Q _4337_/B _5159_/S _7280_/Q VGND VGND VPWR VPWR _3482_/C sky130_fd_sc_hd__a22o_2
XFILLER_44_3 VGND VGND VPWR VPWR sky130_fd_sc_hd__decap_3
XTAP_TAPCELL_ROW_71_1101 VGND VPWR sky130_fd_sc_hd__tapvpwrvgnd_1
XPHY_EDGE_ROW_41_Right_41 VGND VGND VPWR VPWR sky130_fd_sc_hd__decap_3
XFILLER_96_321 VGND VGND VPWR VPWR sky130_fd_sc_hd__decap_3
X_5151_ _5151_/A _5659_/B VGND VGND VPWR VPWR _5151_/X sky130_fd_sc_hd__or2_2
XFILLER_111_632 VGND VGND VPWR VPWR sky130_fd_sc_hd__decap_3
XFILLER_111_665 VGND VGND VPWR VPWR sky130_fd_sc_hd__decap_3
X_5082_ _6986_/Q _5098_/A VGND VGND VPWR VPWR _6986_/D sky130_fd_sc_hd__xor2_2
X_4102_ _7077_/Q _4265_/B VGND VGND VPWR VPWR _4141_/B sky130_fd_sc_hd__nor2_2
XFILLER_110_153 VGND VGND VPWR VPWR sky130_fd_sc_hd__decap_3
XFILLER_111_676 VGND VGND VPWR VPWR sky130_fd_sc_hd__decap_3
XFILLER_2_50 VGND VGND VPWR VPWR sky130_fd_sc_hd__decap_3
XFILLER_84_516 VGND VGND VPWR VPWR sky130_fd_sc_hd__decap_3
XFILLER_96_376 VGND VGND VPWR VPWR sky130_fd_sc_hd__decap_3
X_4033_ _7054_/Q _4482_/S _4437_/B1 _7406_/Q VGND VGND VPWR VPWR _4033_/X sky130_fd_sc_hd__a22o_2
XFILLER_110_186 VGND VGND VPWR VPWR sky130_fd_sc_hd__decap_3
XFILLER_110_197 VGND VGND VPWR VPWR sky130_fd_sc_hd__decap_3
XFILLER_2_83 VGND VGND VPWR VPWR sky130_fd_sc_hd__fill_1
XFILLER_2_94 VGND VGND VPWR VPWR sky130_fd_sc_hd__decap_3
XFILLER_49_270 VGND VGND VPWR VPWR sky130_fd_sc_hd__decap_3
XFILLER_49_292 VGND VGND VPWR VPWR sky130_fd_sc_hd__decap_3
XFILLER_112_29 VGND VGND VPWR VPWR sky130_fd_sc_hd__decap_3
XFILLER_64_251 VGND VGND VPWR VPWR sky130_fd_sc_hd__fill_1
XFILLER_92_560 VGND VGND VPWR VPWR sky130_fd_sc_hd__decap_3
XTAP_TAPCELL_ROW_55_909 VGND VPWR sky130_fd_sc_hd__tapvpwrvgnd_1
XFILLER_24_115 VGND VGND VPWR VPWR sky130_fd_sc_hd__decap_3
XFILLER_25_638 VGND VGND VPWR VPWR sky130_fd_sc_hd__decap_3
XFILLER_37_487 VGND VGND VPWR VPWR sky130_fd_sc_hd__decap_3
XFILLER_52_424 VGND VGND VPWR VPWR sky130_fd_sc_hd__decap_3
XFILLER_64_262 VGND VGND VPWR VPWR sky130_fd_sc_hd__decap_3
XTAP_TAPCELL_ROW_69_1085 VGND VPWR sky130_fd_sc_hd__tapvpwrvgnd_1
XTAP_TAPCELL_ROW_69_1074 VGND VPWR sky130_fd_sc_hd__tapvpwrvgnd_1
XPHY_EDGE_ROW_50_Right_50 VGND VGND VPWR VPWR sky130_fd_sc_hd__decap_3
XFILLER_24_159 VGND VGND VPWR VPWR sky130_fd_sc_hd__decap_3
XTAP_TAPCELL_ROW_82_1241 VGND VPWR sky130_fd_sc_hd__tapvpwrvgnd_1
XTAP_TAPCELL_ROW_82_1230 VGND VPWR sky130_fd_sc_hd__tapvpwrvgnd_1
XFILLER_33_671 VGND VGND VPWR VPWR sky130_fd_sc_hd__fill_1
X_4935_ _6995_/Q _4963_/A VGND VGND VPWR VPWR _6995_/D sky130_fd_sc_hd__xor2_2
XTAP_TAPCELL_ROW_35_677 VGND VPWR sky130_fd_sc_hd__tapvpwrvgnd_1
XTAP_TAPCELL_ROW_35_666 VGND VPWR sky130_fd_sc_hd__tapvpwrvgnd_1
XFILLER_32_170 VGND VGND VPWR VPWR sky130_fd_sc_hd__decap_3
X_6605_ _6638_/A VGND VGND VPWR VPWR _6605_/Y sky130_fd_sc_hd__inv_2
X_4797_ _3526_/B _4648_/A _4795_/A _5033_/B2 VGND VGND VPWR VPWR _4797_/X sky130_fd_sc_hd__a22o_2
X_3817_ _3629_/A _3816_/X _4466_/A VGND VGND VPWR VPWR _3817_/X sky130_fd_sc_hd__a21o_2
XFILLER_21_15 VGND VGND VPWR VPWR sky130_fd_sc_hd__decap_3
X_6536_ _6536_/A VGND VGND VPWR VPWR _6536_/Y sky130_fd_sc_hd__inv_2
X_3748_ _3735_/X _3738_/X _3740_/X _3682_/A _3747_/X VGND VGND VPWR VPWR _3748_/X
+ sky130_fd_sc_hd__a221o_2
XFILLER_106_404 VGND VGND VPWR VPWR sky130_fd_sc_hd__decap_3
XFILLER_4_509 VGND VGND VPWR VPWR sky130_fd_sc_hd__decap_3
XFILLER_106_448 VGND VGND VPWR VPWR sky130_fd_sc_hd__decap_3
X_6467_ _6635_/A VGND VGND VPWR VPWR _6467_/Y sky130_fd_sc_hd__inv_2
X_3679_ _6894_/Q VGND VGND VPWR VPWR _3679_/Y sky130_fd_sc_hd__inv_2
X_6398_ _6647_/A VGND VGND VPWR VPWR _6398_/Y sky130_fd_sc_hd__inv_2
XTAP_TAPCELL_ROW_93_1370 VGND VPWR sky130_fd_sc_hd__tapvpwrvgnd_1
XFILLER_102_621 VGND VGND VPWR VPWR sky130_fd_sc_hd__decap_3
XTAP_TAPCELL_ROW_7_336 VGND VPWR sky130_fd_sc_hd__tapvpwrvgnd_1
XFILLER_102_654 VGND VGND VPWR VPWR sky130_fd_sc_hd__decap_3
XFILLER_101_142 VGND VGND VPWR VPWR sky130_fd_sc_hd__decap_3
XFILLER_102_687 VGND VGND VPWR VPWR sky130_fd_sc_hd__decap_3
XFILLER_75_505 VGND VGND VPWR VPWR sky130_fd_sc_hd__decap_3
XFILLER_101_175 VGND VGND VPWR VPWR sky130_fd_sc_hd__decap_3
XFILLER_101_186 VGND VGND VPWR VPWR sky130_fd_sc_hd__decap_3
XFILLER_28_410 VGND VGND VPWR VPWR sky130_fd_sc_hd__fill_2
XFILLER_28_421 VGND VGND VPWR VPWR sky130_fd_sc_hd__decap_3
XFILLER_46_23 VGND VGND VPWR VPWR sky130_fd_sc_hd__decap_3
X_7019_ _7266_/CLK _7019_/D _6299_/Y VGND VGND VPWR VPWR _7019_/Q sky130_fd_sc_hd__dfrtp_2
XFILLER_16_616 VGND VGND VPWR VPWR sky130_fd_sc_hd__fill_1
XFILLER_46_56 VGND VGND VPWR VPWR sky130_fd_sc_hd__decap_3
XFILLER_55_251 VGND VGND VPWR VPWR sky130_fd_sc_hd__decap_3
XFILLER_55_284 VGND VGND VPWR VPWR sky130_fd_sc_hd__decap_3
XFILLER_102_73 VGND VGND VPWR VPWR sky130_fd_sc_hd__fill_2
XFILLER_23_181 VGND VGND VPWR VPWR sky130_fd_sc_hd__decap_3
XFILLER_62_77 VGND VGND VPWR VPWR sky130_fd_sc_hd__decap_3
XFILLER_62_88 VGND VGND VPWR VPWR sky130_fd_sc_hd__fill_2
XFILLER_70_298 VGND VGND VPWR VPWR sky130_fd_sc_hd__fill_1
XFILLER_7_39 VGND VGND VPWR VPWR sky130_fd_sc_hd__decap_3
XFILLER_109_275 VGND VGND VPWR VPWR sky130_fd_sc_hd__decap_3
XFILLER_7_358 VGND VGND VPWR VPWR sky130_fd_sc_hd__decap_3
XFILLER_11_81 VGND VGND VPWR VPWR sky130_fd_sc_hd__decap_3
XFILLER_112_418 VGND VGND VPWR VPWR sky130_fd_sc_hd__fill_2
XFILLER_87_30 VGND VGND VPWR VPWR sky130_fd_sc_hd__fill_2
XFILLER_97_129 VGND VGND VPWR VPWR sky130_fd_sc_hd__decap_3
XFILLER_87_63 VGND VGND VPWR VPWR sky130_fd_sc_hd__decap_3
XFILLER_87_85 VGND VGND VPWR VPWR sky130_fd_sc_hd__decap_3
XFILLER_78_365 VGND VGND VPWR VPWR sky130_fd_sc_hd__decap_3
XFILLER_59_590 VGND VGND VPWR VPWR sky130_fd_sc_hd__decap_3
XFILLER_78_398 VGND VGND VPWR VPWR sky130_fd_sc_hd__decap_3
XFILLER_46_251 VGND VGND VPWR VPWR sky130_fd_sc_hd__fill_1
XFILLER_81_508 VGND VGND VPWR VPWR sky130_fd_sc_hd__decap_3
XFILLER_46_262 VGND VGND VPWR VPWR sky130_fd_sc_hd__decap_3
XFILLER_46_284 VGND VGND VPWR VPWR sky130_fd_sc_hd__decap_3
XTAP_TAPCELL_ROW_105_1517 VGND VPWR sky130_fd_sc_hd__tapvpwrvgnd_1
XTAP_TAPCELL_ROW_105_1506 VGND VPWR sky130_fd_sc_hd__tapvpwrvgnd_1
XFILLER_30_641 VGND VGND VPWR VPWR sky130_fd_sc_hd__decap_3
Xclkbuf_leaf_41_clk clkbuf_leaf_1_clk/A VGND VGND VPWR VPWR _7352_/CLK sky130_fd_sc_hd__clkbuf_16
X_4720_ _4720_/A _4720_/B VGND VGND VPWR VPWR _4720_/X sky130_fd_sc_hd__xor2_2
XTAP_TAPCELL_ROW_32_636 VGND VPWR sky130_fd_sc_hd__tapvpwrvgnd_1
X_4651_ _4813_/A _4810_/B VGND VGND VPWR VPWR _4652_/B sky130_fd_sc_hd__and2_2
XTAP_TAPCELL_ROW_60_967 VGND VPWR sky130_fd_sc_hd__tapvpwrvgnd_1
X_3602_ _4614_/A _3547_/A _3547_/B _4614_/C _4613_/B VGND VGND VPWR VPWR _3603_/B
+ sky130_fd_sc_hd__a41o_2
X_7370_ _7403_/CLK _7370_/D _6650_/Y VGND VGND VPWR VPWR _7370_/Q sky130_fd_sc_hd__dfrtp_2
XTAP_TAPCELL_ROW_12_393 VGND VPWR sky130_fd_sc_hd__tapvpwrvgnd_1
XFILLER_115_223 VGND VGND VPWR VPWR sky130_fd_sc_hd__fill_1
Xhold804 _6725_/Q VGND VGND VPWR VPWR _6725_/D sky130_fd_sc_hd__dlygate4sd3_1
Xhold815 _6780_/Q VGND VGND VPWR VPWR _6780_/D sky130_fd_sc_hd__dlygate4sd3_1
Xhold826 _6838_/Q VGND VGND VPWR VPWR _6838_/D sky130_fd_sc_hd__dlygate4sd3_1
Xhold837 _6833_/Q VGND VGND VPWR VPWR _6833_/D sky130_fd_sc_hd__dlygate4sd3_1
X_6321_ _6674_/A VGND VGND VPWR VPWR _6321_/Y sky130_fd_sc_hd__inv_2
XTAP_TAPCELL_ROW_116_1657 VGND VPWR sky130_fd_sc_hd__tapvpwrvgnd_1
XTAP_TAPCELL_ROW_116_1646 VGND VPWR sky130_fd_sc_hd__tapvpwrvgnd_1
XFILLER_107_29 VGND VGND VPWR VPWR sky130_fd_sc_hd__decap_3
XFILLER_115_234 VGND VGND VPWR VPWR sky130_fd_sc_hd__decap_3
XFILLER_115_267 VGND VGND VPWR VPWR sky130_fd_sc_hd__decap_3
Xhold848 _7074_/Q VGND VGND VPWR VPWR _7074_/D sky130_fd_sc_hd__dlygate4sd3_1
Xhold859 _7110_/Q VGND VGND VPWR VPWR _7110_/D sky130_fd_sc_hd__dlygate4sd3_1
Xmax_cap567 _4606_/Y VGND VGND VPWR VPWR _4964_/A1 sky130_fd_sc_hd__clkbuf_2
Xmax_cap556 _4647_/C VGND VGND VPWR VPWR _4795_/A sky130_fd_sc_hd__buf_2
XFILLER_88_129 VGND VGND VPWR VPWR sky130_fd_sc_hd__decap_3
X_5203_ _5203_/A _5221_/B VGND VGND VPWR VPWR _7227_/D sky130_fd_sc_hd__and2_2
X_5134_ _3735_/A _3908_/X _3346_/A VGND VGND VPWR VPWR _5134_/X sky130_fd_sc_hd__o21a_2
X_3395_ _7059_/Q _3577_/B VGND VGND VPWR VPWR _3589_/B sky130_fd_sc_hd__nor2_2
XFILLER_97_641 VGND VGND VPWR VPWR sky130_fd_sc_hd__decap_3
XFILLER_57_505 VGND VGND VPWR VPWR sky130_fd_sc_hd__decap_3
XFILLER_57_516 VGND VGND VPWR VPWR sky130_fd_sc_hd__decap_3
XFILLER_97_685 VGND VGND VPWR VPWR sky130_fd_sc_hd__decap_3
XFILLER_111_495 VGND VGND VPWR VPWR sky130_fd_sc_hd__fill_2
XFILLER_57_538 VGND VGND VPWR VPWR sky130_fd_sc_hd__fill_2
X_5065_ _6986_/Q _5098_/A _6987_/Q VGND VGND VPWR VPWR _5066_/B sky130_fd_sc_hd__a21oi_2
XFILLER_84_368 VGND VGND VPWR VPWR sky130_fd_sc_hd__decap_3
XFILLER_16_15 VGND VGND VPWR VPWR sky130_fd_sc_hd__decap_3
XFILLER_25_402 VGND VGND VPWR VPWR sky130_fd_sc_hd__decap_3
XFILLER_16_59 VGND VGND VPWR VPWR sky130_fd_sc_hd__decap_3
XFILLER_25_435 VGND VGND VPWR VPWR sky130_fd_sc_hd__decap_3
XFILLER_25_446 VGND VGND VPWR VPWR sky130_fd_sc_hd__fill_2
XFILLER_52_232 VGND VGND VPWR VPWR sky130_fd_sc_hd__fill_2
XFILLER_80_530 VGND VGND VPWR VPWR sky130_fd_sc_hd__fill_2
XFILLER_12_107 VGND VGND VPWR VPWR sky130_fd_sc_hd__decap_3
XFILLER_40_427 VGND VGND VPWR VPWR sky130_fd_sc_hd__decap_3
XFILLER_40_438 VGND VGND VPWR VPWR sky130_fd_sc_hd__decap_3
XFILLER_40_449 VGND VGND VPWR VPWR sky130_fd_sc_hd__decap_3
Xclkbuf_leaf_32_clk clkbuf_3_2__f_clk/X VGND VGND VPWR VPWR _6972_/CLK sky130_fd_sc_hd__clkbuf_16
X_4918_ _4918_/A _4918_/B VGND VGND VPWR VPWR _4936_/B sky130_fd_sc_hd__nor2_2
X_4849_ _4872_/A _4872_/B VGND VGND VPWR VPWR _4849_/Y sky130_fd_sc_hd__nor2_2
XFILLER_113_6 VGND VGND VPWR VPWR sky130_fd_sc_hd__decap_3
XFILLER_4_328 VGND VGND VPWR VPWR sky130_fd_sc_hd__decap_3
X_6519_ _6553_/A VGND VGND VPWR VPWR _6519_/Y sky130_fd_sc_hd__inv_2
XFILLER_106_234 VGND VGND VPWR VPWR sky130_fd_sc_hd__fill_2
XFILLER_106_245 VGND VGND VPWR VPWR sky130_fd_sc_hd__decap_3
XFILLER_106_256 VGND VGND VPWR VPWR sky130_fd_sc_hd__decap_3
XFILLER_106_289 VGND VGND VPWR VPWR sky130_fd_sc_hd__decap_3
XFILLER_79_107 VGND VGND VPWR VPWR sky130_fd_sc_hd__decap_3
XFILLER_88_641 VGND VGND VPWR VPWR sky130_fd_sc_hd__decap_3
XFILLER_0_589 VGND VGND VPWR VPWR sky130_fd_sc_hd__decap_3
XFILLER_102_451 VGND VGND VPWR VPWR sky130_fd_sc_hd__decap_3
XFILLER_48_516 VGND VGND VPWR VPWR sky130_fd_sc_hd__decap_3
XFILLER_57_11 VGND VGND VPWR VPWR sky130_fd_sc_hd__decap_3
XFILLER_87_140 VGND VGND VPWR VPWR sky130_fd_sc_hd__decap_3
XFILLER_88_663 VGND VGND VPWR VPWR sky130_fd_sc_hd__decap_3
XFILLER_57_77 VGND VGND VPWR VPWR sky130_fd_sc_hd__decap_3
XFILLER_75_335 VGND VGND VPWR VPWR sky130_fd_sc_hd__fill_1
XFILLER_75_346 VGND VGND VPWR VPWR sky130_fd_sc_hd__decap_3
XFILLER_28_240 VGND VGND VPWR VPWR sky130_fd_sc_hd__decap_3
XFILLER_63_508 VGND VGND VPWR VPWR sky130_fd_sc_hd__fill_2
XFILLER_113_72 VGND VGND VPWR VPWR sky130_fd_sc_hd__decap_3
XFILLER_28_262 VGND VGND VPWR VPWR sky130_fd_sc_hd__decap_3
XFILLER_90_316 VGND VGND VPWR VPWR sky130_fd_sc_hd__fill_2
XFILLER_28_295 VGND VGND VPWR VPWR sky130_fd_sc_hd__decap_3
XFILLER_43_221 VGND VGND VPWR VPWR sky130_fd_sc_hd__decap_3
XFILLER_71_541 VGND VGND VPWR VPWR sky130_fd_sc_hd__fill_1
XFILLER_73_87 VGND VGND VPWR VPWR sky130_fd_sc_hd__decap_3
XFILLER_31_438 VGND VGND VPWR VPWR sky130_fd_sc_hd__decap_3
XFILLER_31_449 VGND VGND VPWR VPWR sky130_fd_sc_hd__decap_3
XFILLER_43_287 VGND VGND VPWR VPWR sky130_fd_sc_hd__decap_3
Xclkbuf_leaf_23_clk clkload0/A VGND VGND VPWR VPWR _7386_/CLK sky130_fd_sc_hd__clkbuf_16
XTAP_TAPCELL_ROW_100_1447 VGND VPWR sky130_fd_sc_hd__tapvpwrvgnd_1
XFILLER_12_674 VGND VGND VPWR VPWR sky130_fd_sc_hd__decap_3
XFILLER_78_9 VGND VGND VPWR VPWR sky130_fd_sc_hd__fill_2
XFILLER_7_111 VGND VGND VPWR VPWR sky130_fd_sc_hd__fill_1
XFILLER_7_122 VGND VGND VPWR VPWR sky130_fd_sc_hd__decap_3
XFILLER_8_656 VGND VGND VPWR VPWR sky130_fd_sc_hd__decap_3
XFILLER_7_155 VGND VGND VPWR VPWR sky130_fd_sc_hd__decap_3
XFILLER_22_80 VGND VGND VPWR VPWR sky130_fd_sc_hd__decap_3
XFILLER_98_62 VGND VGND VPWR VPWR sky130_fd_sc_hd__decap_3
XFILLER_112_215 VGND VGND VPWR VPWR sky130_fd_sc_hd__decap_3
XFILLER_3_372 VGND VGND VPWR VPWR sky130_fd_sc_hd__decap_3
XFILLER_98_438 VGND VGND VPWR VPWR sky130_fd_sc_hd__decap_3
XFILLER_112_248 VGND VGND VPWR VPWR sky130_fd_sc_hd__decap_3
XFILLER_79_641 VGND VGND VPWR VPWR sky130_fd_sc_hd__decap_3
XFILLER_78_162 VGND VGND VPWR VPWR sky130_fd_sc_hd__decap_3
XFILLER_79_685 VGND VGND VPWR VPWR sky130_fd_sc_hd__decap_3
XTAP_TAPCELL_ROW_111_1587 VGND VPWR sky130_fd_sc_hd__tapvpwrvgnd_1
XFILLER_66_335 VGND VGND VPWR VPWR sky130_fd_sc_hd__decap_3
XFILLER_78_195 VGND VGND VPWR VPWR sky130_fd_sc_hd__fill_1
XFILLER_94_633 VGND VGND VPWR VPWR sky130_fd_sc_hd__decap_3
XFILLER_66_346 VGND VGND VPWR VPWR sky130_fd_sc_hd__decap_3
XFILLER_66_368 VGND VGND VPWR VPWR sky130_fd_sc_hd__decap_3
XFILLER_93_154 VGND VGND VPWR VPWR sky130_fd_sc_hd__decap_3
XFILLER_94_666 VGND VGND VPWR VPWR sky130_fd_sc_hd__decap_3
XFILLER_19_251 VGND VGND VPWR VPWR sky130_fd_sc_hd__decap_3
XFILLER_19_284 VGND VGND VPWR VPWR sky130_fd_sc_hd__fill_2
XFILLER_34_221 VGND VGND VPWR VPWR sky130_fd_sc_hd__decap_3
XFILLER_34_243 VGND VGND VPWR VPWR sky130_fd_sc_hd__decap_3
XFILLER_62_541 VGND VGND VPWR VPWR sky130_fd_sc_hd__fill_1
X_6870_ _7386_/CLK _6870_/D VGND VGND VPWR VPWR _6870_/Q sky130_fd_sc_hd__dfxtp_2
XTAP_TAPCELL_ROW_66_1044 VGND VPWR sky130_fd_sc_hd__tapvpwrvgnd_1
XFILLER_62_585 VGND VGND VPWR VPWR sky130_fd_sc_hd__decap_3
XTAP_TAPCELL_ROW_17_452 VGND VPWR sky130_fd_sc_hd__tapvpwrvgnd_1
XTAP_TAPCELL_ROW_45_794 VGND VPWR sky130_fd_sc_hd__tapvpwrvgnd_1
Xclkbuf_leaf_14_clk clkload1/A VGND VGND VPWR VPWR _7337_/CLK sky130_fd_sc_hd__clkbuf_16
X_4703_ _6992_/Q _6993_/Q _5001_/A VGND VGND VPWR VPWR _4977_/A sky130_fd_sc_hd__and3_2
XFILLER_8_71 VGND VGND VPWR VPWR sky130_fd_sc_hd__decap_3
X_4634_ _4937_/A _4920_/A _4967_/B _4634_/D VGND VGND VPWR VPWR _4634_/Y sky130_fd_sc_hd__nand4bb_2
X_7353_ _7387_/CLK _7353_/D _6633_/Y VGND VGND VPWR VPWR _7353_/Q sky130_fd_sc_hd__dfrtp_2
Xhold601 _6783_/Q VGND VGND VPWR VPWR _6783_/D sky130_fd_sc_hd__dlygate4sd3_1
Xhold612 _6952_/Q VGND VGND VPWR VPWR _6952_/D sky130_fd_sc_hd__dlygate4sd3_1
X_4565_ _4565_/A _4571_/B VGND VGND VPWR VPWR _7298_/D sky130_fd_sc_hd__and2_2
XFILLER_116_554 VGND VGND VPWR VPWR sky130_fd_sc_hd__decap_3
XFILLER_89_405 VGND VGND VPWR VPWR sky130_fd_sc_hd__decap_3
Xhold623 _6794_/Q VGND VGND VPWR VPWR _6794_/D sky130_fd_sc_hd__dlygate4sd3_1
Xhold634 _6877_/Q VGND VGND VPWR VPWR _6877_/D sky130_fd_sc_hd__dlygate4sd3_1
Xhold645 _6871_/Q VGND VGND VPWR VPWR _6871_/D sky130_fd_sc_hd__dlygate4sd3_1
X_6304_ _6553_/A VGND VGND VPWR VPWR _6304_/Y sky130_fd_sc_hd__inv_2
X_3516_ _5118_/A _3362_/A _5118_/D _3371_/A VGND VGND VPWR VPWR _3516_/X sky130_fd_sc_hd__a211o_2
XTAP_TAPCELL_ROW_77_1173 VGND VPWR sky130_fd_sc_hd__tapvpwrvgnd_1
XFILLER_103_204 VGND VGND VPWR VPWR sky130_fd_sc_hd__fill_2
X_7284_ clkload3/A _7284_/D _6564_/Y VGND VGND VPWR VPWR _7284_/Q sky130_fd_sc_hd__dfrtp_2
Xhold656 _6966_/Q VGND VGND VPWR VPWR _6966_/D sky130_fd_sc_hd__dlygate4sd3_1
Xhold667 _6851_/Q VGND VGND VPWR VPWR _6851_/D sky130_fd_sc_hd__dlygate4sd3_1
Xhold678 _6947_/Q VGND VGND VPWR VPWR _6947_/D sky130_fd_sc_hd__dlygate4sd3_1
XPHY_EDGE_ROW_4_Right_4 VGND VGND VPWR VPWR sky130_fd_sc_hd__decap_3
XFILLER_89_449 VGND VGND VPWR VPWR sky130_fd_sc_hd__fill_2
Xhold689 _6789_/Q VGND VGND VPWR VPWR _6789_/D sky130_fd_sc_hd__dlygate4sd3_1
X_3447_ _7090_/Q _4351_/A2 _3407_/X _7122_/Q VGND VGND VPWR VPWR _3447_/X sky130_fd_sc_hd__a22o_2
XFILLER_85_611 VGND VGND VPWR VPWR sky130_fd_sc_hd__decap_3
X_3378_ _3378_/A _5646_/A VGND VGND VPWR VPWR _3378_/Y sky130_fd_sc_hd__nor2_2
XFILLER_57_313 VGND VGND VPWR VPWR sky130_fd_sc_hd__decap_3
XFILLER_69_184 VGND VGND VPWR VPWR sky130_fd_sc_hd__decap_3
XFILLER_85_644 VGND VGND VPWR VPWR sky130_fd_sc_hd__decap_3
XFILLER_97_482 VGND VGND VPWR VPWR sky130_fd_sc_hd__decap_3
X_5117_ _5595_/B _5117_/B _3896_/Y VGND VGND VPWR VPWR _5117_/X sky130_fd_sc_hd__or3b_2
XFILLER_27_36 VGND VGND VPWR VPWR sky130_fd_sc_hd__decap_3
XFILLER_57_346 VGND VGND VPWR VPWR sky130_fd_sc_hd__decap_3
XFILLER_84_132 VGND VGND VPWR VPWR sky130_fd_sc_hd__decap_3
X_5048_ _5086_/A _5048_/A2 _4621_/X VGND VGND VPWR VPWR _5073_/B sky130_fd_sc_hd__o21bai_2
XFILLER_27_69 VGND VGND VPWR VPWR sky130_fd_sc_hd__decap_3
XFILLER_57_379 VGND VGND VPWR VPWR sky130_fd_sc_hd__decap_3
XFILLER_72_327 VGND VGND VPWR VPWR sky130_fd_sc_hd__decap_3
XFILLER_84_165 VGND VGND VPWR VPWR sky130_fd_sc_hd__decap_3
XFILLER_85_688 VGND VGND VPWR VPWR sky130_fd_sc_hd__decap_3
XFILLER_65_390 VGND VGND VPWR VPWR sky130_fd_sc_hd__fill_2
XFILLER_25_276 VGND VGND VPWR VPWR sky130_fd_sc_hd__decap_3
XFILLER_43_24 VGND VGND VPWR VPWR sky130_fd_sc_hd__decap_3
XFILLER_43_35 VGND VGND VPWR VPWR sky130_fd_sc_hd__decap_3
X_6999_ _7403_/CLK _6999_/D _6279_/Y VGND VGND VPWR VPWR _6999_/Q sky130_fd_sc_hd__dfrtp_2
XFILLER_43_57 VGND VGND VPWR VPWR sky130_fd_sc_hd__decap_3
XFILLER_111_3 VGND VGND VPWR VPWR sky130_fd_sc_hd__decap_3
XFILLER_4_103 VGND VGND VPWR VPWR sky130_fd_sc_hd__decap_3
XFILLER_5_615 VGND VGND VPWR VPWR sky130_fd_sc_hd__fill_1
XFILLER_107_532 VGND VGND VPWR VPWR sky130_fd_sc_hd__fill_1
XFILLER_4_136 VGND VGND VPWR VPWR sky130_fd_sc_hd__decap_3
XFILLER_4_147 VGND VGND VPWR VPWR sky130_fd_sc_hd__decap_3
XFILLER_5_659 VGND VGND VPWR VPWR sky130_fd_sc_hd__decap_3
XFILLER_108_50 VGND VGND VPWR VPWR sky130_fd_sc_hd__decap_3
XFILLER_4_18 VGND VGND VPWR VPWR sky130_fd_sc_hd__decap_3
XFILLER_4_29 VGND VGND VPWR VPWR sky130_fd_sc_hd__decap_3
XFILLER_108_83 VGND VGND VPWR VPWR sky130_fd_sc_hd__fill_1
XFILLER_108_94 VGND VGND VPWR VPWR sky130_fd_sc_hd__decap_3
XFILLER_0_353 VGND VGND VPWR VPWR sky130_fd_sc_hd__decap_3
XFILLER_76_611 VGND VGND VPWR VPWR sky130_fd_sc_hd__fill_1
XFILLER_95_408 VGND VGND VPWR VPWR sky130_fd_sc_hd__decap_3
XFILLER_76_633 VGND VGND VPWR VPWR sky130_fd_sc_hd__decap_3
XFILLER_102_292 VGND VGND VPWR VPWR sky130_fd_sc_hd__decap_3
XFILLER_48_368 VGND VGND VPWR VPWR sky130_fd_sc_hd__fill_1
XFILLER_76_666 VGND VGND VPWR VPWR sky130_fd_sc_hd__decap_3
XFILLER_63_305 VGND VGND VPWR VPWR sky130_fd_sc_hd__decap_3
XFILLER_75_187 VGND VGND VPWR VPWR sky130_fd_sc_hd__decap_3
XFILLER_84_64 VGND VGND VPWR VPWR sky130_fd_sc_hd__decap_3
XFILLER_16_232 VGND VGND VPWR VPWR sky130_fd_sc_hd__decap_3
XFILLER_90_124 VGND VGND VPWR VPWR sky130_fd_sc_hd__decap_3
XFILLER_91_647 VGND VGND VPWR VPWR sky130_fd_sc_hd__decap_3
Xplace327 _5708_/S VGND VGND VPWR VPWR _5706_/S sky130_fd_sc_hd__buf_2
Xplace316 _4327_/A VGND VGND VPWR VPWR _4425_/A sky130_fd_sc_hd__buf_2
Xplace305 _3618_/X VGND VGND VPWR VPWR _4969_/B sky130_fd_sc_hd__buf_2
XFILLER_90_168 VGND VGND VPWR VPWR sky130_fd_sc_hd__decap_3
Xplace349 _4250_/A2 VGND VGND VPWR VPWR _4434_/A2 sky130_fd_sc_hd__buf_2
Xplace338 _5396_/S VGND VGND VPWR VPWR _5386_/S sky130_fd_sc_hd__buf_2
XFILLER_16_276 VGND VGND VPWR VPWR sky130_fd_sc_hd__decap_3
XFILLER_16_298 VGND VGND VPWR VPWR sky130_fd_sc_hd__decap_3
XFILLER_31_202 VGND VGND VPWR VPWR sky130_fd_sc_hd__decap_3
XFILLER_71_371 VGND VGND VPWR VPWR sky130_fd_sc_hd__fill_1
XFILLER_71_393 VGND VGND VPWR VPWR sky130_fd_sc_hd__decap_3
XTAP_TAPCELL_ROW_14_422 VGND VPWR sky130_fd_sc_hd__tapvpwrvgnd_1
XFILLER_31_246 VGND VGND VPWR VPWR sky130_fd_sc_hd__decap_3
XTAP_TAPCELL_ROW_42_753 VGND VPWR sky130_fd_sc_hd__tapvpwrvgnd_1
XFILLER_76_6 VGND VGND VPWR VPWR sky130_fd_sc_hd__decap_3
XFILLER_8_442 VGND VGND VPWR VPWR sky130_fd_sc_hd__decap_3
X_4350_ _7065_/Q _4305_/B _4460_/A VGND VGND VPWR VPWR _4367_/B sky130_fd_sc_hd__o21a_2
XTAP_TAPCELL_ROW_113_1605 VGND VPWR sky130_fd_sc_hd__tapvpwrvgnd_1
X_3301_ _3327_/A _6980_/Q VGND VGND VPWR VPWR _3519_/B sky130_fd_sc_hd__nand2_4
XFILLER_113_535 VGND VGND VPWR VPWR sky130_fd_sc_hd__decap_3
XFILLER_4_681 VGND VGND VPWR VPWR sky130_fd_sc_hd__decap_3
X_4281_ _7254_/Q _3358_/X _4278_/X _4280_/X VGND VGND VPWR VPWR _4281_/X sky130_fd_sc_hd__a211o_2
XFILLER_113_579 VGND VGND VPWR VPWR sky130_fd_sc_hd__decap_3
XFILLER_67_600 VGND VGND VPWR VPWR sky130_fd_sc_hd__decap_3
Xclkbuf_leaf_3_clk clkbuf_leaf_4_clk/A VGND VGND VPWR VPWR _7266_/CLK sky130_fd_sc_hd__clkbuf_16
XFILLER_39_302 VGND VGND VPWR VPWR sky130_fd_sc_hd__fill_1
XFILLER_67_644 VGND VGND VPWR VPWR sky130_fd_sc_hd__decap_3
XFILLER_79_493 VGND VGND VPWR VPWR sky130_fd_sc_hd__fill_2
XFILLER_66_132 VGND VGND VPWR VPWR sky130_fd_sc_hd__decap_3
XFILLER_39_379 VGND VGND VPWR VPWR sky130_fd_sc_hd__fill_2
XFILLER_54_305 VGND VGND VPWR VPWR sky130_fd_sc_hd__decap_3
XFILLER_66_165 VGND VGND VPWR VPWR sky130_fd_sc_hd__decap_3
XFILLER_67_688 VGND VGND VPWR VPWR sky130_fd_sc_hd__decap_3
XFILLER_81_113 VGND VGND VPWR VPWR sky130_fd_sc_hd__decap_3
XFILLER_82_625 VGND VGND VPWR VPWR sky130_fd_sc_hd__decap_3
XFILLER_81_146 VGND VGND VPWR VPWR sky130_fd_sc_hd__decap_3
XFILLER_82_669 VGND VGND VPWR VPWR sky130_fd_sc_hd__decap_3
X_6922_ _7384_/CLK _6922_/D VGND VGND VPWR VPWR _6922_/Q sky130_fd_sc_hd__dfxtp_2
X_6853_ _6978_/CLK _6853_/D VGND VGND VPWR VPWR _6853_/Q sky130_fd_sc_hd__dfxtp_2
XFILLER_50_522 VGND VGND VPWR VPWR sky130_fd_sc_hd__decap_3
XFILLER_62_371 VGND VGND VPWR VPWR sky130_fd_sc_hd__decap_3
Xfanout17 _6536_/A VGND VGND VPWR VPWR _6347_/A sky130_fd_sc_hd__buf_2
Xfanout28 _6600_/A VGND VGND VPWR VPWR _6664_/A sky130_fd_sc_hd__clkdlybuf4s25_1
XFILLER_22_246 VGND VGND VPWR VPWR sky130_fd_sc_hd__decap_3
Xfanout39 fanout51/X VGND VGND VPWR VPWR fanout39/X sky130_fd_sc_hd__buf_1
X_6784_ clkload2/A _6784_/D VGND VGND VPWR VPWR _6784_/Q sky130_fd_sc_hd__dfxtp_2
X_3996_ _7344_/Q _4534_/A0 _3996_/S VGND VGND VPWR VPWR _7344_/D sky130_fd_sc_hd__mux2_2
XFILLER_13_38 VGND VGND VPWR VPWR sky130_fd_sc_hd__decap_3
XFILLER_22_279 VGND VGND VPWR VPWR sky130_fd_sc_hd__decap_3
X_5735_ _7373_/Q hold954/X _5737_/S VGND VGND VPWR VPWR _5735_/X sky130_fd_sc_hd__mux2_2
XFILLER_108_307 VGND VGND VPWR VPWR sky130_fd_sc_hd__fill_1
X_5666_ _5666_/A _5666_/B VGND VGND VPWR VPWR _5668_/B sky130_fd_sc_hd__or2_2
XTAP_TAPCELL_ROW_79_1202 VGND VPWR sky130_fd_sc_hd__tapvpwrvgnd_1
X_7405_ _7405_/CLK _7405_/D _6685_/Y VGND VGND VPWR VPWR _7405_/Q sky130_fd_sc_hd__dfrtp_2
X_4617_ _5114_/B _4617_/B _4617_/C VGND VGND VPWR VPWR _5099_/A sky130_fd_sc_hd__or3_4
XFILLER_116_340 VGND VGND VPWR VPWR sky130_fd_sc_hd__fill_2
X_5597_ hold947/X _5587_/B _5154_/Y VGND VGND VPWR VPWR _7029_/D sky130_fd_sc_hd__a21o_2
XFILLER_116_362 VGND VGND VPWR VPWR sky130_fd_sc_hd__fill_2
X_7336_ _7368_/CLK _7336_/D _6616_/Y VGND VGND VPWR VPWR _7336_/Q sky130_fd_sc_hd__dfrtp_2
X_4548_ _4548_/A _4563_/B VGND VGND VPWR VPWR _7306_/D sky130_fd_sc_hd__and2_2
XFILLER_1_128 VGND VGND VPWR VPWR sky130_fd_sc_hd__decap_3
X_7267_ _7363_/CLK _7267_/D _6547_/Y VGND VGND VPWR VPWR _7267_/Q sky130_fd_sc_hd__dfrtp_2
XFILLER_77_408 VGND VGND VPWR VPWR sky130_fd_sc_hd__decap_3
XFILLER_38_24 VGND VGND VPWR VPWR sky130_fd_sc_hd__decap_3
XFILLER_58_622 VGND VGND VPWR VPWR sky130_fd_sc_hd__decap_3
X_7198_ _7390_/CLK _7198_/D _6478_/Y VGND VGND VPWR VPWR _7198_/Q sky130_fd_sc_hd__dfrtp_2
XFILLER_38_57 VGND VGND VPWR VPWR sky130_fd_sc_hd__decap_3
XFILLER_38_79 VGND VGND VPWR VPWR sky130_fd_sc_hd__decap_3
XFILLER_58_666 VGND VGND VPWR VPWR sky130_fd_sc_hd__decap_3
XFILLER_85_441 VGND VGND VPWR VPWR sky130_fd_sc_hd__decap_3
XFILLER_85_452 VGND VGND VPWR VPWR sky130_fd_sc_hd__decap_3
XFILLER_97_290 VGND VGND VPWR VPWR sky130_fd_sc_hd__decap_3
Xhold1120 _7170_/Q VGND VGND VPWR VPWR _5321_/A0 sky130_fd_sc_hd__dlygate4sd3_1
Xhold1131 _7159_/Q VGND VGND VPWR VPWR _5344_/A0 sky130_fd_sc_hd__dlygate4sd3_1
Xhold1142 _7145_/Q VGND VGND VPWR VPWR _5375_/A0 sky130_fd_sc_hd__dlygate4sd3_1
XFILLER_73_614 VGND VGND VPWR VPWR sky130_fd_sc_hd__fill_2
XFILLER_85_474 VGND VGND VPWR VPWR sky130_fd_sc_hd__decap_3
Xhold1153 _7166_/Q VGND VGND VPWR VPWR _5329_/A0 sky130_fd_sc_hd__dlygate4sd3_1
Xhold1164 _7272_/Q VGND VGND VPWR VPWR _4823_/A0 sky130_fd_sc_hd__dlygate4sd3_1
Xhold1175 _7143_/Q VGND VGND VPWR VPWR _5379_/A0 sky130_fd_sc_hd__dlygate4sd3_1
XPHY_EDGE_ROW_79_Right_79 VGND VGND VPWR VPWR sky130_fd_sc_hd__decap_3
XFILLER_26_541 VGND VGND VPWR VPWR sky130_fd_sc_hd__decap_3
XFILLER_54_12 VGND VGND VPWR VPWR sky130_fd_sc_hd__decap_3
XFILLER_57_198 VGND VGND VPWR VPWR sky130_fd_sc_hd__decap_3
XFILLER_73_647 VGND VGND VPWR VPWR sky130_fd_sc_hd__decap_3
Xhold1186 _7306_/Q VGND VGND VPWR VPWR _4548_/A sky130_fd_sc_hd__dlygate4sd3_1
Xhold1197 _7169_/Q VGND VGND VPWR VPWR _5323_/A0 sky130_fd_sc_hd__dlygate4sd3_1
XFILLER_54_45 VGND VGND VPWR VPWR sky130_fd_sc_hd__decap_3
XFILLER_54_56 VGND VGND VPWR VPWR sky130_fd_sc_hd__decap_3
XFILLER_72_168 VGND VGND VPWR VPWR sky130_fd_sc_hd__decap_3
XFILLER_13_202 VGND VGND VPWR VPWR sky130_fd_sc_hd__decap_3
XFILLER_41_533 VGND VGND VPWR VPWR sky130_fd_sc_hd__decap_3
XFILLER_53_393 VGND VGND VPWR VPWR sky130_fd_sc_hd__decap_3
XFILLER_81_691 VGND VGND VPWR VPWR sky130_fd_sc_hd__fill_1
XFILLER_110_62 VGND VGND VPWR VPWR sky130_fd_sc_hd__decap_3
XFILLER_13_246 VGND VGND VPWR VPWR sky130_fd_sc_hd__decap_3
XFILLER_80_190 VGND VGND VPWR VPWR sky130_fd_sc_hd__decap_3
XFILLER_13_268 VGND VGND VPWR VPWR sky130_fd_sc_hd__decap_3
XFILLER_41_588 VGND VGND VPWR VPWR sky130_fd_sc_hd__decap_3
XFILLER_9_217 VGND VGND VPWR VPWR sky130_fd_sc_hd__fill_2
XFILLER_70_55 VGND VGND VPWR VPWR sky130_fd_sc_hd__decap_3
XPHY_EDGE_ROW_88_Right_88 VGND VGND VPWR VPWR sky130_fd_sc_hd__decap_3
XFILLER_5_423 VGND VGND VPWR VPWR sky130_fd_sc_hd__decap_3
XFILLER_79_20 VGND VGND VPWR VPWR sky130_fd_sc_hd__decap_3
XFILLER_107_351 VGND VGND VPWR VPWR sky130_fd_sc_hd__decap_3
XFILLER_79_75 VGND VGND VPWR VPWR sky130_fd_sc_hd__decap_3
XFILLER_1_640 VGND VGND VPWR VPWR sky130_fd_sc_hd__decap_3
XFILLER_49_600 VGND VGND VPWR VPWR sky130_fd_sc_hd__decap_3
XFILLER_0_161 VGND VGND VPWR VPWR sky130_fd_sc_hd__decap_3
XFILLER_1_673 VGND VGND VPWR VPWR sky130_fd_sc_hd__decap_3
XFILLER_49_644 VGND VGND VPWR VPWR sky130_fd_sc_hd__decap_3
XFILLER_76_430 VGND VGND VPWR VPWR sky130_fd_sc_hd__decap_3
XFILLER_95_63 VGND VGND VPWR VPWR sky130_fd_sc_hd__decap_3
XPHY_EDGE_ROW_97_Right_97 VGND VGND VPWR VPWR sky130_fd_sc_hd__decap_3
XFILLER_49_688 VGND VGND VPWR VPWR sky130_fd_sc_hd__decap_3
XFILLER_64_625 VGND VGND VPWR VPWR sky130_fd_sc_hd__decap_3
XFILLER_76_463 VGND VGND VPWR VPWR sky130_fd_sc_hd__decap_3
XTAP_TAPCELL_ROW_47_812 VGND VPWR sky130_fd_sc_hd__tapvpwrvgnd_1
XFILLER_63_113 VGND VGND VPWR VPWR sky130_fd_sc_hd__fill_2
XFILLER_64_669 VGND VGND VPWR VPWR sky130_fd_sc_hd__decap_3
XFILLER_91_444 VGND VGND VPWR VPWR sky130_fd_sc_hd__decap_3
XFILLER_91_488 VGND VGND VPWR VPWR sky130_fd_sc_hd__decap_3
XFILLER_44_371 VGND VGND VPWR VPWR sky130_fd_sc_hd__decap_3
XFILLER_91_499 VGND VGND VPWR VPWR sky130_fd_sc_hd__fill_2
XTAP_TAPCELL_ROW_63_1003 VGND VPWR sky130_fd_sc_hd__tapvpwrvgnd_1
XTAP_TAPCELL_ROW_27_580 VGND VPWR sky130_fd_sc_hd__tapvpwrvgnd_1
XFILLER_71_190 VGND VGND VPWR VPWR sky130_fd_sc_hd__decap_3
X_3850_ _6810_/Q _3656_/Y _3917_/B1 _6820_/Q VGND VGND VPWR VPWR _3850_/X sky130_fd_sc_hd__a22o_2
XPHY_EDGE_ROW_4_Left_121 VGND VGND VPWR VPWR sky130_fd_sc_hd__decap_3
X_3781_ _6949_/Q _3893_/B1 _3665_/X _6961_/Q _3780_/X VGND VGND VPWR VPWR _3781_/X
+ sky130_fd_sc_hd__a221o_2
XFILLER_8_283 VGND VGND VPWR VPWR sky130_fd_sc_hd__decap_3
Xoutput536 _6999_/Q VGND VGND VPWR VPWR pc_out[22] sky130_fd_sc_hd__clkdlybuf4s25_1
Xoutput525 _6989_/Q VGND VGND VPWR VPWR pc_out[12] sky130_fd_sc_hd__clkdlybuf4s25_1
Xoutput514 _7412_/X VGND VGND VPWR VPWR instruction_out[30] sky130_fd_sc_hd__clkdlybuf4s25_1
Xoutput503 _5161_/A VGND VGND VPWR VPWR instruction_out[18] sky130_fd_sc_hd__clkdlybuf4s25_1
X_4402_ _7082_/Q _4432_/A2 _4432_/B1 _4401_/X VGND VGND VPWR VPWR _4403_/A sky130_fd_sc_hd__o211a_2
XFILLER_99_511 VGND VGND VPWR VPWR sky130_fd_sc_hd__decap_3
XFILLER_113_321 VGND VGND VPWR VPWR sky130_fd_sc_hd__decap_3
XFILLER_5_72 VGND VGND VPWR VPWR sky130_fd_sc_hd__decap_3
X_7121_ _7352_/CLK _7121_/D _6401_/Y VGND VGND VPWR VPWR _7121_/Q sky130_fd_sc_hd__dfrtp_2
Xoutput547 _6980_/Q VGND VGND VPWR VPWR pc_out[3] sky130_fd_sc_hd__clkdlybuf4s25_1
X_4333_ _7127_/Q _3407_/X _4332_/X VGND VGND VPWR VPWR _4336_/A sky130_fd_sc_hd__a21o_2
XTAP_TAPCELL_ROW_74_1143 VGND VPWR sky130_fd_sc_hd__tapvpwrvgnd_1
XFILLER_99_533 VGND VGND VPWR VPWR sky130_fd_sc_hd__decap_3
XFILLER_113_343 VGND VGND VPWR VPWR sky130_fd_sc_hd__decap_3
XFILLER_113_354 VGND VGND VPWR VPWR sky130_fd_sc_hd__decap_3
X_7052_ _7374_/CLK _7052_/D _6332_/Y VGND VGND VPWR VPWR _7052_/Q sky130_fd_sc_hd__dfrtp_2
X_4264_ _4264_/A _4264_/B VGND VGND VPWR VPWR _4376_/B sky130_fd_sc_hd__nor2_2
XFILLER_115_29 VGND VGND VPWR VPWR sky130_fd_sc_hd__decap_3
XFILLER_86_238 VGND VGND VPWR VPWR sky130_fd_sc_hd__decap_3
XFILLER_67_430 VGND VGND VPWR VPWR sky130_fd_sc_hd__decap_3
XFILLER_86_249 VGND VGND VPWR VPWR sky130_fd_sc_hd__decap_3
X_4195_ _7135_/Q _4195_/A2 _4352_/B1 _7167_/Q VGND VGND VPWR VPWR _4195_/X sky130_fd_sc_hd__a22o_2
XFILLER_27_305 VGND VGND VPWR VPWR sky130_fd_sc_hd__decap_3
XFILLER_39_154 VGND VGND VPWR VPWR sky130_fd_sc_hd__decap_3
XFILLER_55_603 VGND VGND VPWR VPWR sky130_fd_sc_hd__decap_3
XFILLER_67_463 VGND VGND VPWR VPWR sky130_fd_sc_hd__decap_3
XFILLER_82_411 VGND VGND VPWR VPWR sky130_fd_sc_hd__decap_3
XFILLER_94_271 VGND VGND VPWR VPWR sky130_fd_sc_hd__decap_3
XFILLER_54_124 VGND VGND VPWR VPWR sky130_fd_sc_hd__decap_3
XFILLER_54_135 VGND VGND VPWR VPWR sky130_fd_sc_hd__decap_3
XFILLER_55_647 VGND VGND VPWR VPWR sky130_fd_sc_hd__decap_3
XFILLER_54_168 VGND VGND VPWR VPWR sky130_fd_sc_hd__decap_3
XFILLER_70_628 VGND VGND VPWR VPWR sky130_fd_sc_hd__decap_3
XFILLER_82_477 VGND VGND VPWR VPWR sky130_fd_sc_hd__fill_1
X_6905_ _6965_/CLK _6905_/D VGND VGND VPWR VPWR _6905_/Q sky130_fd_sc_hd__dfxtp_2
XTAP_TAPCELL_ROW_85_1272 VGND VPWR sky130_fd_sc_hd__tapvpwrvgnd_1
XFILLER_24_26 VGND VGND VPWR VPWR sky130_fd_sc_hd__fill_2
XFILLER_24_48 VGND VGND VPWR VPWR sky130_fd_sc_hd__fill_2
XFILLER_35_393 VGND VGND VPWR VPWR sky130_fd_sc_hd__decap_3
X_6836_ _6972_/CLK _6836_/D VGND VGND VPWR VPWR _6836_/Q sky130_fd_sc_hd__dfxtp_2
XPHY_EDGE_ROW_59_Left_176 VGND VGND VPWR VPWR sky130_fd_sc_hd__decap_3
X_6767_ _6975_/CLK _6767_/D VGND VGND VPWR VPWR _6767_/Q sky130_fd_sc_hd__dfxtp_2
X_3979_ _7351_/Q _7319_/Q _3987_/S VGND VGND VPWR VPWR _7351_/D sky130_fd_sc_hd__mux2_2
XFILLER_108_115 VGND VGND VPWR VPWR sky130_fd_sc_hd__decap_3
XFILLER_109_638 VGND VGND VPWR VPWR sky130_fd_sc_hd__decap_3
XFILLER_40_36 VGND VGND VPWR VPWR sky130_fd_sc_hd__decap_3
X_6698_ _7386_/CLK _6698_/D VGND VGND VPWR VPWR _6698_/Q sky130_fd_sc_hd__dfxtp_2
XFILLER_40_69 VGND VGND VPWR VPWR sky130_fd_sc_hd__decap_3
X_5649_ _5649_/A VGND VGND VPWR VPWR _5649_/X sky130_fd_sc_hd__buf_1
XFILLER_2_404 VGND VGND VPWR VPWR sky130_fd_sc_hd__decap_3
XFILLER_104_321 VGND VGND VPWR VPWR sky130_fd_sc_hd__decap_3
XFILLER_116_181 VGND VGND VPWR VPWR sky130_fd_sc_hd__fill_1
XFILLER_2_448 VGND VGND VPWR VPWR sky130_fd_sc_hd__decap_3
XFILLER_49_12 VGND VGND VPWR VPWR sky130_fd_sc_hd__decap_3
XFILLER_6_6 VGND VGND VPWR VPWR sky130_fd_sc_hd__decap_3
X_7319_ clkload3/A _7319_/D _6599_/Y VGND VGND VPWR VPWR _7319_/Q sky130_fd_sc_hd__dfrtp_2
XPHY_EDGE_ROW_68_Left_185 VGND VGND VPWR VPWR sky130_fd_sc_hd__decap_3
XFILLER_104_365 VGND VGND VPWR VPWR sky130_fd_sc_hd__decap_3
XFILLER_49_45 VGND VGND VPWR VPWR sky130_fd_sc_hd__decap_3
XFILLER_104_398 VGND VGND VPWR VPWR sky130_fd_sc_hd__fill_1
XFILLER_105_51 VGND VGND VPWR VPWR sky130_fd_sc_hd__decap_3
XFILLER_58_441 VGND VGND VPWR VPWR sky130_fd_sc_hd__fill_2
XFILLER_105_95 VGND VGND VPWR VPWR sky130_fd_sc_hd__fill_2
XFILLER_45_113 VGND VGND VPWR VPWR sky130_fd_sc_hd__decap_3
XFILLER_65_66 VGND VGND VPWR VPWR sky130_fd_sc_hd__decap_3
XFILLER_73_422 VGND VGND VPWR VPWR sky130_fd_sc_hd__decap_3
XFILLER_73_444 VGND VGND VPWR VPWR sky130_fd_sc_hd__decap_3
XFILLER_45_146 VGND VGND VPWR VPWR sky130_fd_sc_hd__fill_1
XFILLER_46_669 VGND VGND VPWR VPWR sky130_fd_sc_hd__decap_3
XFILLER_61_617 VGND VGND VPWR VPWR sky130_fd_sc_hd__decap_3
XFILLER_65_99 VGND VGND VPWR VPWR sky130_fd_sc_hd__decap_3
XFILLER_14_522 VGND VGND VPWR VPWR sky130_fd_sc_hd__fill_2
XFILLER_60_105 VGND VGND VPWR VPWR sky130_fd_sc_hd__decap_3
XPHY_EDGE_ROW_77_Left_194 VGND VGND VPWR VPWR sky130_fd_sc_hd__decap_3
XFILLER_53_190 VGND VGND VPWR VPWR sky130_fd_sc_hd__fill_1
XFILLER_60_138 VGND VGND VPWR VPWR sky130_fd_sc_hd__fill_2
XFILLER_81_21 VGND VGND VPWR VPWR sky130_fd_sc_hd__decap_3
XFILLER_81_54 VGND VGND VPWR VPWR sky130_fd_sc_hd__fill_2
XTAP_TAPCELL_ROW_52_881 VGND VPWR sky130_fd_sc_hd__tapvpwrvgnd_1
XTAP_TAPCELL_ROW_52_870 VGND VPWR sky130_fd_sc_hd__tapvpwrvgnd_1
XFILLER_81_98 VGND VGND VPWR VPWR sky130_fd_sc_hd__decap_3
XFILLER_60_9 VGND VGND VPWR VPWR sky130_fd_sc_hd__decap_3
XFILLER_108_660 VGND VGND VPWR VPWR sky130_fd_sc_hd__decap_3
XFILLER_114_118 VGND VGND VPWR VPWR sky130_fd_sc_hd__decap_3
XFILLER_30_80 VGND VGND VPWR VPWR sky130_fd_sc_hd__decap_3
XFILLER_30_91 VGND VGND VPWR VPWR sky130_fd_sc_hd__decap_3
XFILLER_96_503 VGND VGND VPWR VPWR sky130_fd_sc_hd__decap_3
XFILLER_39_6 VGND VGND VPWR VPWR sky130_fd_sc_hd__decap_3
XFILLER_96_525 VGND VGND VPWR VPWR sky130_fd_sc_hd__decap_3
XFILLER_96_558 VGND VGND VPWR VPWR sky130_fd_sc_hd__decap_3
XFILLER_110_368 VGND VGND VPWR VPWR sky130_fd_sc_hd__decap_3
XFILLER_49_452 VGND VGND VPWR VPWR sky130_fd_sc_hd__decap_3
XFILLER_49_474 VGND VGND VPWR VPWR sky130_fd_sc_hd__decap_3
XFILLER_76_282 VGND VGND VPWR VPWR sky130_fd_sc_hd__decap_3
XTAP_TAPCELL_ROW_108_1548 VGND VPWR sky130_fd_sc_hd__tapvpwrvgnd_1
XFILLER_64_466 VGND VGND VPWR VPWR sky130_fd_sc_hd__decap_3
XFILLER_64_477 VGND VGND VPWR VPWR sky130_fd_sc_hd__fill_1
XFILLER_17_360 VGND VGND VPWR VPWR sky130_fd_sc_hd__decap_3
XFILLER_17_382 VGND VGND VPWR VPWR sky130_fd_sc_hd__decap_3
XFILLER_45_691 VGND VGND VPWR VPWR sky130_fd_sc_hd__fill_1
XFILLER_51_116 VGND VGND VPWR VPWR sky130_fd_sc_hd__decap_3
XFILLER_52_628 VGND VGND VPWR VPWR sky130_fd_sc_hd__decap_3
XFILLER_91_274 VGND VGND VPWR VPWR sky130_fd_sc_hd__decap_3
X_4951_ _4949_/Y _4950_/Y _4918_/B VGND VGND VPWR VPWR _4951_/Y sky130_fd_sc_hd__a21oi_2
X_4882_ _4882_/A _4882_/B VGND VGND VPWR VPWR _6998_/D sky130_fd_sc_hd__and2_2
X_3902_ _6918_/Q _3902_/A2 _3925_/B1 _6870_/Q VGND VGND VPWR VPWR _3902_/X sky130_fd_sc_hd__a22o_2
XFILLER_32_352 VGND VGND VPWR VPWR sky130_fd_sc_hd__decap_3
XFILLER_60_672 VGND VGND VPWR VPWR sky130_fd_sc_hd__decap_3
X_6621_ _6682_/A VGND VGND VPWR VPWR _6621_/Y sky130_fd_sc_hd__inv_2
X_3833_ _3833_/A0 _3832_/X _3864_/S VGND VGND VPWR VPWR _7388_/D sky130_fd_sc_hd__mux2_2
X_6552_ _6584_/A VGND VGND VPWR VPWR _6552_/Y sky130_fd_sc_hd__inv_2
X_3764_ _6706_/Q _6796_/Q _6884_/Q _6932_/Q _3991_/B _3665_/B VGND VGND VPWR VPWR
+ _3764_/X sky130_fd_sc_hd__mux4_2
XFILLER_9_570 VGND VGND VPWR VPWR sky130_fd_sc_hd__decap_3
X_6483_ _6483_/A VGND VGND VPWR VPWR _6483_/Y sky130_fd_sc_hd__inv_2
X_3695_ _6714_/Q _3767_/A2 _3767_/B1 _6892_/Q VGND VGND VPWR VPWR _3695_/X sky130_fd_sc_hd__a22o_2
XFILLER_113_140 VGND VGND VPWR VPWR sky130_fd_sc_hd__decap_3
XFILLER_114_663 VGND VGND VPWR VPWR sky130_fd_sc_hd__decap_3
X_7104_ _7294_/CLK _7104_/D _6384_/Y VGND VGND VPWR VPWR _7104_/Q sky130_fd_sc_hd__dfrtp_2
X_5365_ _5365_/A0 _4716_/X _5386_/S VGND VGND VPWR VPWR _7150_/D sky130_fd_sc_hd__mux2_4
XFILLER_101_302 VGND VGND VPWR VPWR sky130_fd_sc_hd__decap_3
XFILLER_101_313 VGND VGND VPWR VPWR sky130_fd_sc_hd__decap_3
XFILLER_59_205 VGND VGND VPWR VPWR sky130_fd_sc_hd__fill_2
X_5296_ _5296_/A0 _4716_/X _5315_/S VGND VGND VPWR VPWR _7182_/D sky130_fd_sc_hd__mux2_4
X_4316_ _7226_/Q _4349_/B1 _4348_/B1 _7130_/Q VGND VGND VPWR VPWR _4316_/X sky130_fd_sc_hd__a22o_2
XFILLER_99_396 VGND VGND VPWR VPWR sky130_fd_sc_hd__decap_3
XFILLER_101_346 VGND VGND VPWR VPWR sky130_fd_sc_hd__fill_1
XFILLER_113_184 VGND VGND VPWR VPWR sky130_fd_sc_hd__decap_3
XFILLER_19_26 VGND VGND VPWR VPWR sky130_fd_sc_hd__fill_2
X_7035_ clkload9/A _7035_/D _6315_/Y VGND VGND VPWR VPWR _7035_/Q sky130_fd_sc_hd__dfrtp_2
X_4247_ _7261_/Q _4356_/A2 _3964_/S _7325_/Q _4246_/X VGND VGND VPWR VPWR _4248_/C
+ sky130_fd_sc_hd__a221o_2
XFILLER_28_614 VGND VGND VPWR VPWR sky130_fd_sc_hd__decap_3
X_4178_ _7264_/Q _4356_/A2 _4177_/X VGND VGND VPWR VPWR _4178_/Y sky130_fd_sc_hd__a21oi_2
XTAP_TAPCELL_ROW_87_1301 VGND VPWR sky130_fd_sc_hd__tapvpwrvgnd_1
XFILLER_27_102 VGND VGND VPWR VPWR sky130_fd_sc_hd__decap_3
XFILLER_27_113 VGND VGND VPWR VPWR sky130_fd_sc_hd__decap_3
XFILLER_27_146 VGND VGND VPWR VPWR sky130_fd_sc_hd__fill_1
XFILLER_28_669 VGND VGND VPWR VPWR sky130_fd_sc_hd__decap_3
XFILLER_35_14 VGND VGND VPWR VPWR sky130_fd_sc_hd__decap_3
XTAP_TAPCELL_ROW_2_278 VGND VPWR sky130_fd_sc_hd__tapvpwrvgnd_1
XFILLER_70_436 VGND VGND VPWR VPWR sky130_fd_sc_hd__decap_3
XFILLER_82_296 VGND VGND VPWR VPWR sky130_fd_sc_hd__fill_1
XFILLER_23_330 VGND VGND VPWR VPWR sky130_fd_sc_hd__decap_3
XFILLER_51_650 VGND VGND VPWR VPWR sky130_fd_sc_hd__decap_3
XFILLER_11_514 VGND VGND VPWR VPWR sky130_fd_sc_hd__fill_2
XFILLER_23_374 VGND VGND VPWR VPWR sky130_fd_sc_hd__decap_3
X_6819_ _6976_/CLK _6819_/D VGND VGND VPWR VPWR _6819_/Q sky130_fd_sc_hd__dfxtp_2
XFILLER_50_182 VGND VGND VPWR VPWR sky130_fd_sc_hd__decap_3
XFILLER_109_402 VGND VGND VPWR VPWR sky130_fd_sc_hd__decap_3
XFILLER_51_57 VGND VGND VPWR VPWR sky130_fd_sc_hd__decap_3
XTAP_TAPCELL_ROW_98_1430 VGND VPWR sky130_fd_sc_hd__tapvpwrvgnd_1
XFILLER_105_641 VGND VGND VPWR VPWR sky130_fd_sc_hd__decap_3
XFILLER_4_3 VGND VGND VPWR VPWR sky130_fd_sc_hd__decap_3
XFILLER_105_685 VGND VGND VPWR VPWR sky130_fd_sc_hd__decap_3
XFILLER_116_50 VGND VGND VPWR VPWR sky130_fd_sc_hd__decap_3
XFILLER_2_267 VGND VGND VPWR VPWR sky130_fd_sc_hd__decap_3
XFILLER_116_83 VGND VGND VPWR VPWR sky130_fd_sc_hd__fill_1
XFILLER_116_94 VGND VGND VPWR VPWR sky130_fd_sc_hd__decap_3
XFILLER_76_32 VGND VGND VPWR VPWR sky130_fd_sc_hd__decap_3
XFILLER_65_208 VGND VGND VPWR VPWR sky130_fd_sc_hd__decap_3
XFILLER_76_65 VGND VGND VPWR VPWR sky130_fd_sc_hd__fill_1
XFILLER_93_517 VGND VGND VPWR VPWR sky130_fd_sc_hd__decap_3
XFILLER_18_124 VGND VGND VPWR VPWR sky130_fd_sc_hd__decap_3
XFILLER_46_433 VGND VGND VPWR VPWR sky130_fd_sc_hd__decap_3
XFILLER_58_293 VGND VGND VPWR VPWR sky130_fd_sc_hd__decap_3
XFILLER_46_477 VGND VGND VPWR VPWR sky130_fd_sc_hd__fill_2
Xplace75 _5657_/B VGND VGND VPWR VPWR place75/X sky130_fd_sc_hd__buf_2
XTAP_TAPCELL_ROW_57_940 VGND VPWR sky130_fd_sc_hd__tapvpwrvgnd_1
XPHY_EDGE_ROW_85_Left_202 VGND VGND VPWR VPWR sky130_fd_sc_hd__decap_3
XFILLER_34_639 VGND VGND VPWR VPWR sky130_fd_sc_hd__decap_3
XFILLER_73_263 VGND VGND VPWR VPWR sky130_fd_sc_hd__decap_3
XFILLER_73_296 VGND VGND VPWR VPWR sky130_fd_sc_hd__decap_3
XFILLER_33_149 VGND VGND VPWR VPWR sky130_fd_sc_hd__decap_3
XFILLER_61_447 VGND VGND VPWR VPWR sky130_fd_sc_hd__fill_1
XFILLER_92_97 VGND VGND VPWR VPWR sky130_fd_sc_hd__decap_3
XFILLER_14_374 VGND VGND VPWR VPWR sky130_fd_sc_hd__decap_3
XFILLER_42_683 VGND VGND VPWR VPWR sky130_fd_sc_hd__decap_3
XTAP_TAPCELL_ROW_103_1489 VGND VPWR sky130_fd_sc_hd__tapvpwrvgnd_1
XPHY_EDGE_ROW_94_Left_211 VGND VGND VPWR VPWR sky130_fd_sc_hd__decap_3
XFILLER_41_90 VGND VGND VPWR VPWR sky130_fd_sc_hd__decap_3
X_3480_ _7088_/Q _4351_/A2 _4351_/B1 _7120_/Q VGND VGND VPWR VPWR _3482_/B sky130_fd_sc_hd__a22o_2
XFILLER_115_449 VGND VGND VPWR VPWR sky130_fd_sc_hd__fill_2
XTAP_TAPCELL_ROW_71_1102 VGND VPWR sky130_fd_sc_hd__tapvpwrvgnd_1
XFILLER_111_600 VGND VGND VPWR VPWR sky130_fd_sc_hd__decap_3
XFILLER_37_3 VGND VGND VPWR VPWR sky130_fd_sc_hd__decap_3
XFILLER_69_503 VGND VGND VPWR VPWR sky130_fd_sc_hd__fill_1
XFILLER_69_525 VGND VGND VPWR VPWR sky130_fd_sc_hd__decap_3
XFILLER_96_300 VGND VGND VPWR VPWR sky130_fd_sc_hd__decap_3
X_5150_ _3501_/X _3618_/X _5145_/X _5149_/Y VGND VGND VPWR VPWR _5659_/B sky130_fd_sc_hd__a31o_2
XFILLER_110_121 VGND VGND VPWR VPWR sky130_fd_sc_hd__decap_3
XFILLER_111_644 VGND VGND VPWR VPWR sky130_fd_sc_hd__decap_3
XFILLER_96_333 VGND VGND VPWR VPWR sky130_fd_sc_hd__fill_2
X_4101_ _7141_/Q _4420_/B1 _4100_/X VGND VGND VPWR VPWR _4141_/A sky130_fd_sc_hd__a21oi_2
XFILLER_110_165 VGND VGND VPWR VPWR sky130_fd_sc_hd__decap_3
XFILLER_111_688 VGND VGND VPWR VPWR sky130_fd_sc_hd__decap_3
XFILLER_2_62 VGND VGND VPWR VPWR sky130_fd_sc_hd__decap_3
X_4032_ _7246_/Q _4433_/B _3935_/S _7214_/Q VGND VGND VPWR VPWR _4032_/X sky130_fd_sc_hd__a22o_2
XFILLER_37_422 VGND VGND VPWR VPWR sky130_fd_sc_hd__decap_3
XFILLER_77_591 VGND VGND VPWR VPWR sky130_fd_sc_hd__decap_3
XFILLER_96_399 VGND VGND VPWR VPWR sky130_fd_sc_hd__decap_3
XFILLER_25_617 VGND VGND VPWR VPWR sky130_fd_sc_hd__decap_3
XTAP_TAPCELL_ROW_69_1075 VGND VPWR sky130_fd_sc_hd__tapvpwrvgnd_1
XFILLER_24_138 VGND VGND VPWR VPWR sky130_fd_sc_hd__fill_2
XFILLER_40_609 VGND VGND VPWR VPWR sky130_fd_sc_hd__fill_1
XFILLER_52_436 VGND VGND VPWR VPWR sky130_fd_sc_hd__decap_3
XTAP_TAPCELL_ROW_82_1231 VGND VPWR sky130_fd_sc_hd__tapvpwrvgnd_1
XTAP_TAPCELL_ROW_35_667 VGND VPWR sky130_fd_sc_hd__tapvpwrvgnd_1
XFILLER_32_182 VGND VGND VPWR VPWR sky130_fd_sc_hd__fill_2
XFILLER_60_480 VGND VGND VPWR VPWR sky130_fd_sc_hd__decap_3
X_4865_ _4865_/A0 _4864_/X _4901_/S VGND VGND VPWR VPWR _7270_/D sky130_fd_sc_hd__mux2_2
X_6604_ _6604_/A VGND VGND VPWR VPWR _6604_/Y sky130_fd_sc_hd__inv_2
X_4796_ _4795_/A _4779_/X _4447_/B _4780_/Y _4814_/A VGND VGND VPWR VPWR _4796_/Y
+ sky130_fd_sc_hd__a311oi_2
X_3816_ _6792_/Q _3862_/B1 _3925_/B1 _6880_/Q _3815_/X VGND VGND VPWR VPWR _3816_/X
+ sky130_fd_sc_hd__a221o_2
X_6535_ _6535_/A VGND VGND VPWR VPWR _6535_/Y sky130_fd_sc_hd__inv_2
X_3747_ _3741_/X _3743_/X _3745_/X _3746_/X VGND VGND VPWR VPWR _3747_/X sky130_fd_sc_hd__a22o_2
XFILLER_106_427 VGND VGND VPWR VPWR sky130_fd_sc_hd__fill_1
XFILLER_108_9 VGND VGND VPWR VPWR sky130_fd_sc_hd__decap_3
X_6466_ _6634_/A VGND VGND VPWR VPWR _6466_/Y sky130_fd_sc_hd__inv_2
X_6397_ _6558_/A VGND VGND VPWR VPWR _6397_/Y sky130_fd_sc_hd__inv_2
X_5417_ _5417_/A0 _5125_/Y _5423_/S VGND VGND VPWR VPWR _7125_/D sky130_fd_sc_hd__mux2_2
X_5348_ _7157_/Q _5125_/Y _5358_/S VGND VGND VPWR VPWR _7157_/D sky130_fd_sc_hd__mux2_2
XTAP_TAPCELL_ROW_93_1371 VGND VPWR sky130_fd_sc_hd__tapvpwrvgnd_1
XTAP_TAPCELL_ROW_7_337 VGND VPWR sky130_fd_sc_hd__tapvpwrvgnd_1
XFILLER_101_110 VGND VGND VPWR VPWR sky130_fd_sc_hd__fill_2
XFILLER_101_132 VGND VGND VPWR VPWR sky130_fd_sc_hd__fill_2
XFILLER_102_633 VGND VGND VPWR VPWR sky130_fd_sc_hd__decap_3
XFILLER_102_666 VGND VGND VPWR VPWR sky130_fd_sc_hd__decap_3
XFILLER_47_208 VGND VGND VPWR VPWR sky130_fd_sc_hd__decap_3
X_7018_ _7363_/CLK _7018_/D _6298_/Y VGND VGND VPWR VPWR _7018_/Q sky130_fd_sc_hd__dfrtp_2
XFILLER_28_433 VGND VGND VPWR VPWR sky130_fd_sc_hd__fill_1
XFILLER_68_580 VGND VGND VPWR VPWR sky130_fd_sc_hd__fill_1
XFILLER_28_444 VGND VGND VPWR VPWR sky130_fd_sc_hd__decap_3
XFILLER_46_68 VGND VGND VPWR VPWR sky130_fd_sc_hd__decap_3
XFILLER_28_477 VGND VGND VPWR VPWR sky130_fd_sc_hd__decap_3
XFILLER_43_403 VGND VGND VPWR VPWR sky130_fd_sc_hd__decap_3
XFILLER_55_263 VGND VGND VPWR VPWR sky130_fd_sc_hd__decap_3
XFILLER_70_200 VGND VGND VPWR VPWR sky130_fd_sc_hd__decap_3
XFILLER_83_572 VGND VGND VPWR VPWR sky130_fd_sc_hd__fill_2
XFILLER_102_52 VGND VGND VPWR VPWR sky130_fd_sc_hd__decap_3
XFILLER_15_127 VGND VGND VPWR VPWR sky130_fd_sc_hd__decap_3
XFILLER_43_436 VGND VGND VPWR VPWR sky130_fd_sc_hd__decap_3
XFILLER_43_458 VGND VGND VPWR VPWR sky130_fd_sc_hd__decap_3
XFILLER_62_12 VGND VGND VPWR VPWR sky130_fd_sc_hd__decap_3
XFILLER_70_222 VGND VGND VPWR VPWR sky130_fd_sc_hd__fill_2
XFILLER_102_85 VGND VGND VPWR VPWR sky130_fd_sc_hd__decap_3
XFILLER_70_277 VGND VGND VPWR VPWR sky130_fd_sc_hd__decap_3
XFILLER_11_322 VGND VGND VPWR VPWR sky130_fd_sc_hd__decap_3
XFILLER_11_366 VGND VGND VPWR VPWR sky130_fd_sc_hd__fill_2
XFILLER_23_193 VGND VGND VPWR VPWR sky130_fd_sc_hd__fill_1
XFILLER_7_18 VGND VGND VPWR VPWR sky130_fd_sc_hd__decap_3
XFILLER_11_388 VGND VGND VPWR VPWR sky130_fd_sc_hd__decap_3
XFILLER_7_337 VGND VGND VPWR VPWR sky130_fd_sc_hd__decap_3
XFILLER_11_60 VGND VGND VPWR VPWR sky130_fd_sc_hd__decap_3
XFILLER_112_408 VGND VGND VPWR VPWR sky130_fd_sc_hd__fill_2
XFILLER_11_93 VGND VGND VPWR VPWR sky130_fd_sc_hd__decap_3
XFILLER_105_471 VGND VGND VPWR VPWR sky130_fd_sc_hd__decap_3
XFILLER_3_587 VGND VGND VPWR VPWR sky130_fd_sc_hd__decap_3
XFILLER_78_300 VGND VGND VPWR VPWR sky130_fd_sc_hd__decap_3
XFILLER_105_493 VGND VGND VPWR VPWR sky130_fd_sc_hd__fill_2
XFILLER_78_333 VGND VGND VPWR VPWR sky130_fd_sc_hd__decap_3
XFILLER_87_53 VGND VGND VPWR VPWR sky130_fd_sc_hd__decap_3
XFILLER_23_9 VGND VGND VPWR VPWR sky130_fd_sc_hd__decap_3
XFILLER_66_506 VGND VGND VPWR VPWR sky130_fd_sc_hd__decap_3
XFILLER_93_347 VGND VGND VPWR VPWR sky130_fd_sc_hd__decap_3
XFILLER_46_230 VGND VGND VPWR VPWR sky130_fd_sc_hd__decap_3
XFILLER_61_211 VGND VGND VPWR VPWR sky130_fd_sc_hd__decap_3
XTAP_TAPCELL_ROW_105_1507 VGND VPWR sky130_fd_sc_hd__tapvpwrvgnd_1
XFILLER_61_255 VGND VGND VPWR VPWR sky130_fd_sc_hd__decap_3
XFILLER_42_480 VGND VGND VPWR VPWR sky130_fd_sc_hd__decap_3
XTAP_TAPCELL_ROW_32_637 VGND VPWR sky130_fd_sc_hd__tapvpwrvgnd_1
XFILLER_30_664 VGND VGND VPWR VPWR sky130_fd_sc_hd__fill_2
X_4650_ _4440_/A _4650_/B VGND VGND VPWR VPWR _4810_/B sky130_fd_sc_hd__and2b_2
XTAP_TAPCELL_ROW_60_968 VGND VPWR sky130_fd_sc_hd__tapvpwrvgnd_1
X_3601_ _3427_/B _3600_/Y _3599_/A VGND VGND VPWR VPWR _4613_/B sky130_fd_sc_hd__a21oi_2
X_6320_ _6644_/A VGND VGND VPWR VPWR _6320_/Y sky130_fd_sc_hd__inv_2
X_4581_ _7290_/Q _4595_/B VGND VGND VPWR VPWR _7290_/D sky130_fd_sc_hd__and2_2
XTAP_TAPCELL_ROW_12_394 VGND VPWR sky130_fd_sc_hd__tapvpwrvgnd_1
XFILLER_115_202 VGND VGND VPWR VPWR sky130_fd_sc_hd__decap_3
Xhold805 _6831_/Q VGND VGND VPWR VPWR _6831_/D sky130_fd_sc_hd__dlygate4sd3_1
Xhold816 _6724_/Q VGND VGND VPWR VPWR _6724_/D sky130_fd_sc_hd__dlygate4sd3_1
Xhold827 _6728_/Q VGND VGND VPWR VPWR _6728_/D sky130_fd_sc_hd__dlygate4sd3_1
X_3532_ _3327_/A _3509_/Y _5642_/B _5659_/A _4268_/A2 VGND VGND VPWR VPWR _3621_/A
+ sky130_fd_sc_hd__a41o_2
XTAP_TAPCELL_ROW_116_1658 VGND VPWR sky130_fd_sc_hd__tapvpwrvgnd_1
XTAP_TAPCELL_ROW_116_1647 VGND VPWR sky130_fd_sc_hd__tapvpwrvgnd_1
XFILLER_115_246 VGND VGND VPWR VPWR sky130_fd_sc_hd__decap_3
Xhold838 _6772_/Q VGND VGND VPWR VPWR _6772_/D sky130_fd_sc_hd__dlygate4sd3_1
Xhold849 _7118_/Q VGND VGND VPWR VPWR _7118_/D sky130_fd_sc_hd__dlygate4sd3_1
Xmax_cap557 _4069_/Y VGND VGND VPWR VPWR _4745_/A sky130_fd_sc_hd__clkbuf_2
X_3463_ _7057_/Q _3577_/B _4460_/A _3462_/X VGND VGND VPWR VPWR _3545_/A sky130_fd_sc_hd__o211ai_4
XFILLER_115_279 VGND VGND VPWR VPWR sky130_fd_sc_hd__fill_1
XFILLER_88_108 VGND VGND VPWR VPWR sky130_fd_sc_hd__decap_3
XFILLER_97_620 VGND VGND VPWR VPWR sky130_fd_sc_hd__decap_3
XFILLER_96_130 VGND VGND VPWR VPWR sky130_fd_sc_hd__decap_3
X_3394_ _3394_/A _3429_/B VGND VGND VPWR VPWR _4305_/B sky130_fd_sc_hd__or2_2
XFILLER_97_653 VGND VGND VPWR VPWR sky130_fd_sc_hd__decap_3
XFILLER_96_141 VGND VGND VPWR VPWR sky130_fd_sc_hd__decap_3
XFILLER_69_388 VGND VGND VPWR VPWR sky130_fd_sc_hd__fill_1
XFILLER_84_325 VGND VGND VPWR VPWR sky130_fd_sc_hd__decap_3
XFILLER_72_509 VGND VGND VPWR VPWR sky130_fd_sc_hd__decap_3
XFILLER_84_347 VGND VGND VPWR VPWR sky130_fd_sc_hd__decap_3
XFILLER_25_414 VGND VGND VPWR VPWR sky130_fd_sc_hd__fill_1
XFILLER_37_263 VGND VGND VPWR VPWR sky130_fd_sc_hd__decap_3
XFILLER_65_594 VGND VGND VPWR VPWR sky130_fd_sc_hd__decap_3
XFILLER_16_27 VGND VGND VPWR VPWR sky130_fd_sc_hd__fill_1
XFILLER_16_38 VGND VGND VPWR VPWR sky130_fd_sc_hd__decap_3
XFILLER_25_458 VGND VGND VPWR VPWR sky130_fd_sc_hd__decap_3
XFILLER_80_553 VGND VGND VPWR VPWR sky130_fd_sc_hd__decap_3
XFILLER_92_380 VGND VGND VPWR VPWR sky130_fd_sc_hd__decap_3
XFILLER_12_119 VGND VGND VPWR VPWR sky130_fd_sc_hd__decap_3
XFILLER_33_480 VGND VGND VPWR VPWR sky130_fd_sc_hd__decap_3
XFILLER_80_597 VGND VGND VPWR VPWR sky130_fd_sc_hd__decap_3
X_4917_ _4967_/A _4950_/A _4967_/B VGND VGND VPWR VPWR _4918_/B sky130_fd_sc_hd__and3_2
XFILLER_20_141 VGND VGND VPWR VPWR sky130_fd_sc_hd__decap_3
XFILLER_32_37 VGND VGND VPWR VPWR sky130_fd_sc_hd__decap_3
X_4848_ _4884_/A _4904_/B _4140_/X VGND VGND VPWR VPWR _4872_/B sky130_fd_sc_hd__o21ba_2
XFILLER_4_307 VGND VGND VPWR VPWR sky130_fd_sc_hd__fill_1
X_4779_ _4779_/A _4827_/B VGND VGND VPWR VPWR _4779_/X sky130_fd_sc_hd__or2_2
X_6518_ _6675_/A VGND VGND VPWR VPWR _6518_/Y sky130_fd_sc_hd__inv_2
XFILLER_106_6 VGND VGND VPWR VPWR sky130_fd_sc_hd__decap_3
X_6449_ _6611_/A VGND VGND VPWR VPWR _6449_/Y sky130_fd_sc_hd__inv_2
XFILLER_0_502 VGND VGND VPWR VPWR sky130_fd_sc_hd__fill_2
XFILLER_106_268 VGND VGND VPWR VPWR sky130_fd_sc_hd__decap_3
XFILLER_79_119 VGND VGND VPWR VPWR sky130_fd_sc_hd__fill_2
XFILLER_102_430 VGND VGND VPWR VPWR sky130_fd_sc_hd__decap_3
XFILLER_88_620 VGND VGND VPWR VPWR sky130_fd_sc_hd__decap_3
XFILLER_0_557 VGND VGND VPWR VPWR sky130_fd_sc_hd__decap_3
XFILLER_102_463 VGND VGND VPWR VPWR sky130_fd_sc_hd__decap_3
XFILLER_57_23 VGND VGND VPWR VPWR sky130_fd_sc_hd__fill_1
XFILLER_57_34 VGND VGND VPWR VPWR sky130_fd_sc_hd__decap_3
XFILLER_87_152 VGND VGND VPWR VPWR sky130_fd_sc_hd__decap_3
XFILLER_88_675 VGND VGND VPWR VPWR sky130_fd_sc_hd__decap_3
XFILLER_102_485 VGND VGND VPWR VPWR sky130_fd_sc_hd__decap_3
XFILLER_113_51 VGND VGND VPWR VPWR sky130_fd_sc_hd__decap_3
XFILLER_28_274 VGND VGND VPWR VPWR sky130_fd_sc_hd__decap_3
XFILLER_90_339 VGND VGND VPWR VPWR sky130_fd_sc_hd__decap_3
XFILLER_113_84 VGND VGND VPWR VPWR sky130_fd_sc_hd__decap_3
XFILLER_16_447 VGND VGND VPWR VPWR sky130_fd_sc_hd__decap_3
XFILLER_43_233 VGND VGND VPWR VPWR sky130_fd_sc_hd__decap_3
XFILLER_73_55 VGND VGND VPWR VPWR sky130_fd_sc_hd__fill_1
XFILLER_83_380 VGND VGND VPWR VPWR sky130_fd_sc_hd__decap_3
XFILLER_43_277 VGND VGND VPWR VPWR sky130_fd_sc_hd__decap_3
XFILLER_71_586 VGND VGND VPWR VPWR sky130_fd_sc_hd__decap_3
XFILLER_43_299 VGND VGND VPWR VPWR sky130_fd_sc_hd__decap_3
XTAP_TAPCELL_ROW_100_1448 VGND VPWR sky130_fd_sc_hd__tapvpwrvgnd_1
XFILLER_11_185 VGND VGND VPWR VPWR sky130_fd_sc_hd__decap_3
XFILLER_22_70 VGND VGND VPWR VPWR sky130_fd_sc_hd__decap_3
XFILLER_7_134 VGND VGND VPWR VPWR sky130_fd_sc_hd__decap_3
XFILLER_8_668 VGND VGND VPWR VPWR sky130_fd_sc_hd__decap_3
XFILLER_7_178 VGND VGND VPWR VPWR sky130_fd_sc_hd__decap_3
XFILLER_98_85 VGND VGND VPWR VPWR sky130_fd_sc_hd__decap_3
XFILLER_98_74 VGND VGND VPWR VPWR sky130_fd_sc_hd__fill_2
XFILLER_98_406 VGND VGND VPWR VPWR sky130_fd_sc_hd__decap_3
XFILLER_112_227 VGND VGND VPWR VPWR sky130_fd_sc_hd__decap_3
XFILLER_3_384 VGND VGND VPWR VPWR sky130_fd_sc_hd__decap_3
XFILLER_79_620 VGND VGND VPWR VPWR sky130_fd_sc_hd__decap_3
XFILLER_21_6 VGND VGND VPWR VPWR sky130_fd_sc_hd__decap_3
XFILLER_78_141 VGND VGND VPWR VPWR sky130_fd_sc_hd__decap_3
XFILLER_79_653 VGND VGND VPWR VPWR sky130_fd_sc_hd__decap_3
XFILLER_94_612 VGND VGND VPWR VPWR sky130_fd_sc_hd__decap_3
XTAP_TAPCELL_ROW_111_1588 VGND VPWR sky130_fd_sc_hd__tapvpwrvgnd_1
XFILLER_93_100 VGND VGND VPWR VPWR sky130_fd_sc_hd__decap_3
XFILLER_93_111 VGND VGND VPWR VPWR sky130_fd_sc_hd__fill_1
XFILLER_94_645 VGND VGND VPWR VPWR sky130_fd_sc_hd__decap_3
XFILLER_93_144 VGND VGND VPWR VPWR sky130_fd_sc_hd__decap_3
XFILLER_94_678 VGND VGND VPWR VPWR sky130_fd_sc_hd__decap_3
XFILLER_19_274 VGND VGND VPWR VPWR sky130_fd_sc_hd__decap_3
XFILLER_34_200 VGND VGND VPWR VPWR sky130_fd_sc_hd__decap_3
XFILLER_47_561 VGND VGND VPWR VPWR sky130_fd_sc_hd__fill_2
XFILLER_81_317 VGND VGND VPWR VPWR sky130_fd_sc_hd__decap_3
XFILLER_93_166 VGND VGND VPWR VPWR sky130_fd_sc_hd__fill_2
XFILLER_19_296 VGND VGND VPWR VPWR sky130_fd_sc_hd__decap_3
XTAP_TAPCELL_ROW_66_1045 VGND VPWR sky130_fd_sc_hd__tapvpwrvgnd_1
XFILLER_62_553 VGND VGND VPWR VPWR sky130_fd_sc_hd__fill_1
XTAP_TAPCELL_ROW_17_453 VGND VPWR sky130_fd_sc_hd__tapvpwrvgnd_1
XTAP_TAPCELL_ROW_45_795 VGND VPWR sky130_fd_sc_hd__tapvpwrvgnd_1
XPHY_EDGE_ROW_22_Left_139 VGND VGND VPWR VPWR sky130_fd_sc_hd__decap_3
X_4702_ _6991_/Q _5026_/A VGND VGND VPWR VPWR _5001_/A sky130_fd_sc_hd__and2_2
XFILLER_8_50 VGND VGND VPWR VPWR sky130_fd_sc_hd__decap_3
X_5682_ _7347_/Q hold932/X _5708_/S VGND VGND VPWR VPWR _5682_/X sky130_fd_sc_hd__mux2_2
XFILLER_30_494 VGND VGND VPWR VPWR sky130_fd_sc_hd__decap_3
XFILLER_8_83 VGND VGND VPWR VPWR sky130_fd_sc_hd__fill_1
XFILLER_8_94 VGND VGND VPWR VPWR sky130_fd_sc_hd__decap_3
X_4633_ _4633_/A _4903_/A _4845_/A _4890_/B VGND VGND VPWR VPWR _4633_/X sky130_fd_sc_hd__or4_2
XFILLER_116_522 VGND VGND VPWR VPWR sky130_fd_sc_hd__decap_3
X_7352_ _7352_/CLK _7352_/D _6632_/Y VGND VGND VPWR VPWR _7352_/Q sky130_fd_sc_hd__dfrtp_2
Xhold602 _6933_/Q VGND VGND VPWR VPWR _6933_/D sky130_fd_sc_hd__dlygate4sd3_1
XFILLER_116_533 VGND VGND VPWR VPWR sky130_fd_sc_hd__fill_1
X_7283_ clkload3/A _7283_/D _6563_/Y VGND VGND VPWR VPWR _7283_/Q sky130_fd_sc_hd__dfrtp_2
Xhold613 _6977_/Q VGND VGND VPWR VPWR _6977_/D sky130_fd_sc_hd__dlygate4sd3_1
Xhold624 _6891_/Q VGND VGND VPWR VPWR _6891_/D sky130_fd_sc_hd__dlygate4sd3_1
Xhold635 _6916_/Q VGND VGND VPWR VPWR _6916_/D sky130_fd_sc_hd__dlygate4sd3_1
X_6303_ _6611_/A VGND VGND VPWR VPWR _6303_/Y sky130_fd_sc_hd__inv_2
X_3515_ _3509_/Y _3510_/X _4196_/A2 VGND VGND VPWR VPWR _4938_/A sky130_fd_sc_hd__a21o_2
XTAP_TAPCELL_ROW_77_1174 VGND VPWR sky130_fd_sc_hd__tapvpwrvgnd_1
XFILLER_116_577 VGND VGND VPWR VPWR sky130_fd_sc_hd__decap_3
Xhold646 _6960_/Q VGND VGND VPWR VPWR _6960_/D sky130_fd_sc_hd__dlygate4sd3_1
Xhold657 _6778_/Q VGND VGND VPWR VPWR _6778_/D sky130_fd_sc_hd__dlygate4sd3_1
Xhold668 _6757_/Q VGND VGND VPWR VPWR _6757_/D sky130_fd_sc_hd__dlygate4sd3_1
Xhold679 _6948_/Q VGND VGND VPWR VPWR _6948_/D sky130_fd_sc_hd__dlygate4sd3_1
X_4495_ _4495_/A0 _4561_/A _4505_/S VGND VGND VPWR VPWR _7332_/D sky130_fd_sc_hd__mux2_2
XPHY_EDGE_ROW_31_Left_148 VGND VGND VPWR VPWR sky130_fd_sc_hd__decap_3
XTAP_TAPCELL_ROW_90_1330 VGND VPWR sky130_fd_sc_hd__tapvpwrvgnd_1
XFILLER_69_130 VGND VGND VPWR VPWR sky130_fd_sc_hd__decap_3
XFILLER_69_141 VGND VGND VPWR VPWR sky130_fd_sc_hd__decap_3
XFILLER_97_461 VGND VGND VPWR VPWR sky130_fd_sc_hd__decap_3
X_3377_ _3394_/A _3429_/A _5641_/A _5161_/A VGND VGND VPWR VPWR _3377_/X sky130_fd_sc_hd__and4bb_4
XFILLER_57_325 VGND VGND VPWR VPWR sky130_fd_sc_hd__decap_3
XFILLER_69_163 VGND VGND VPWR VPWR sky130_fd_sc_hd__fill_2
XFILLER_84_111 VGND VGND VPWR VPWR sky130_fd_sc_hd__decap_3
XFILLER_85_623 VGND VGND VPWR VPWR sky130_fd_sc_hd__decap_3
X_5116_ _5110_/Y _5111_/X _5115_/X VGND VGND VPWR VPWR _5658_/D sky130_fd_sc_hd__o21ai_4
XFILLER_111_293 VGND VGND VPWR VPWR sky130_fd_sc_hd__decap_3
XFILLER_27_15 VGND VGND VPWR VPWR sky130_fd_sc_hd__decap_3
XFILLER_57_358 VGND VGND VPWR VPWR sky130_fd_sc_hd__decap_3
XFILLER_69_196 VGND VGND VPWR VPWR sky130_fd_sc_hd__decap_3
XFILLER_84_144 VGND VGND VPWR VPWR sky130_fd_sc_hd__decap_3
XFILLER_85_656 VGND VGND VPWR VPWR sky130_fd_sc_hd__decap_3
X_5047_ _5114_/B _4617_/B _4617_/C _5100_/A VGND VGND VPWR VPWR _5047_/Y sky130_fd_sc_hd__o31ai_1
XFILLER_27_48 VGND VGND VPWR VPWR sky130_fd_sc_hd__decap_3
XFILLER_38_583 VGND VGND VPWR VPWR sky130_fd_sc_hd__decap_3
XFILLER_25_222 VGND VGND VPWR VPWR sky130_fd_sc_hd__fill_2
XFILLER_72_339 VGND VGND VPWR VPWR sky130_fd_sc_hd__decap_3
XFILLER_80_361 VGND VGND VPWR VPWR sky130_fd_sc_hd__decap_3
X_6998_ _7403_/CLK _6998_/D _6278_/Y VGND VGND VPWR VPWR _6998_/Q sky130_fd_sc_hd__dfrtp_2
XPHY_EDGE_ROW_40_Left_157 VGND VGND VPWR VPWR sky130_fd_sc_hd__decap_3
XFILLER_40_214 VGND VGND VPWR VPWR sky130_fd_sc_hd__decap_3
XFILLER_53_586 VGND VGND VPWR VPWR sky130_fd_sc_hd__decap_3
XFILLER_40_247 VGND VGND VPWR VPWR sky130_fd_sc_hd__decap_3
XFILLER_21_472 VGND VGND VPWR VPWR sky130_fd_sc_hd__decap_3
XFILLER_107_511 VGND VGND VPWR VPWR sky130_fd_sc_hd__decap_3
XFILLER_4_115 VGND VGND VPWR VPWR sky130_fd_sc_hd__decap_3
XFILLER_104_3 VGND VGND VPWR VPWR sky130_fd_sc_hd__decap_3
XFILLER_107_544 VGND VGND VPWR VPWR sky130_fd_sc_hd__decap_3
XFILLER_108_62 VGND VGND VPWR VPWR sky130_fd_sc_hd__decap_3
XFILLER_4_159 VGND VGND VPWR VPWR sky130_fd_sc_hd__decap_3
XFILLER_68_11 VGND VGND VPWR VPWR sky130_fd_sc_hd__decap_3
XFILLER_68_55 VGND VGND VPWR VPWR sky130_fd_sc_hd__decap_3
XFILLER_68_77 VGND VGND VPWR VPWR sky130_fd_sc_hd__decap_3
XFILLER_76_601 VGND VGND VPWR VPWR sky130_fd_sc_hd__decap_3
XFILLER_0_365 VGND VGND VPWR VPWR sky130_fd_sc_hd__decap_3
XFILLER_102_271 VGND VGND VPWR VPWR sky130_fd_sc_hd__decap_3
XFILLER_68_88 VGND VGND VPWR VPWR sky130_fd_sc_hd__decap_3
XFILLER_76_645 VGND VGND VPWR VPWR sky130_fd_sc_hd__decap_3
XFILLER_76_678 VGND VGND VPWR VPWR sky130_fd_sc_hd__decap_3
XFILLER_84_21 VGND VGND VPWR VPWR sky130_fd_sc_hd__fill_2
XFILLER_84_32 VGND VGND VPWR VPWR sky130_fd_sc_hd__decap_3
XFILLER_29_561 VGND VGND VPWR VPWR sky130_fd_sc_hd__decap_3
XFILLER_75_166 VGND VGND VPWR VPWR sky130_fd_sc_hd__fill_2
XFILLER_90_103 VGND VGND VPWR VPWR sky130_fd_sc_hd__decap_3
XFILLER_91_615 VGND VGND VPWR VPWR sky130_fd_sc_hd__fill_1
XFILLER_91_626 VGND VGND VPWR VPWR sky130_fd_sc_hd__decap_3
XFILLER_16_200 VGND VGND VPWR VPWR sky130_fd_sc_hd__decap_3
XFILLER_44_531 VGND VGND VPWR VPWR sky130_fd_sc_hd__fill_1
XFILLER_84_76 VGND VGND VPWR VPWR sky130_fd_sc_hd__decap_3
XFILLER_90_147 VGND VGND VPWR VPWR sky130_fd_sc_hd__decap_3
XFILLER_91_659 VGND VGND VPWR VPWR sky130_fd_sc_hd__decap_3
Xplace328 _5721_/S VGND VGND VPWR VPWR _5737_/S sky130_fd_sc_hd__buf_2
Xplace317 _3424_/S VGND VGND VPWR VPWR _4327_/A sky130_fd_sc_hd__buf_2
Xplace306 _3586_/Y VGND VGND VPWR VPWR _3600_/A sky130_fd_sc_hd__buf_2
XFILLER_17_81 VGND VGND VPWR VPWR sky130_fd_sc_hd__decap_3
XFILLER_71_350 VGND VGND VPWR VPWR sky130_fd_sc_hd__decap_3
Xplace339 _5429_/S VGND VGND VPWR VPWR _5423_/S sky130_fd_sc_hd__buf_2
XFILLER_16_288 VGND VGND VPWR VPWR sky130_fd_sc_hd__decap_3
XFILLER_31_225 VGND VGND VPWR VPWR sky130_fd_sc_hd__decap_3
XTAP_TAPCELL_ROW_42_754 VGND VPWR sky130_fd_sc_hd__tapvpwrvgnd_1
XTAP_TAPCELL_ROW_14_423 VGND VPWR sky130_fd_sc_hd__tapvpwrvgnd_1
XFILLER_31_269 VGND VGND VPWR VPWR sky130_fd_sc_hd__fill_2
XFILLER_8_421 VGND VGND VPWR VPWR sky130_fd_sc_hd__decap_3
XFILLER_8_454 VGND VGND VPWR VPWR sky130_fd_sc_hd__decap_3
XFILLER_69_6 VGND VGND VPWR VPWR sky130_fd_sc_hd__decap_3
XTAP_TAPCELL_ROW_113_1606 VGND VPWR sky130_fd_sc_hd__tapvpwrvgnd_1
XFILLER_113_503 VGND VGND VPWR VPWR sky130_fd_sc_hd__fill_1
XFILLER_4_660 VGND VGND VPWR VPWR sky130_fd_sc_hd__decap_3
X_3300_ _3403_/A VGND VGND VPWR VPWR _4467_/A sky130_fd_sc_hd__inv_2
XFILLER_113_547 VGND VGND VPWR VPWR sky130_fd_sc_hd__decap_3
X_4280_ _7222_/Q _3377_/X _4339_/B1 _7158_/Q _4279_/X VGND VGND VPWR VPWR _4280_/X
+ sky130_fd_sc_hd__a221o_2
XFILLER_98_269 VGND VGND VPWR VPWR sky130_fd_sc_hd__decap_3
XFILLER_39_314 VGND VGND VPWR VPWR sky130_fd_sc_hd__decap_3
XFILLER_39_325 VGND VGND VPWR VPWR sky130_fd_sc_hd__decap_3
XFILLER_66_111 VGND VGND VPWR VPWR sky130_fd_sc_hd__decap_3
XFILLER_67_612 VGND VGND VPWR VPWR sky130_fd_sc_hd__decap_3
XFILLER_67_623 VGND VGND VPWR VPWR sky130_fd_sc_hd__decap_3
XFILLER_66_144 VGND VGND VPWR VPWR sky130_fd_sc_hd__decap_3
XFILLER_67_656 VGND VGND VPWR VPWR sky130_fd_sc_hd__decap_3
XFILLER_54_317 VGND VGND VPWR VPWR sky130_fd_sc_hd__decap_3
XFILLER_66_177 VGND VGND VPWR VPWR sky130_fd_sc_hd__decap_3
XFILLER_82_604 VGND VGND VPWR VPWR sky130_fd_sc_hd__decap_3
XFILLER_82_637 VGND VGND VPWR VPWR sky130_fd_sc_hd__decap_3
XFILLER_94_475 VGND VGND VPWR VPWR sky130_fd_sc_hd__fill_1
XFILLER_81_125 VGND VGND VPWR VPWR sky130_fd_sc_hd__decap_3
XFILLER_82_648 VGND VGND VPWR VPWR sky130_fd_sc_hd__decap_3
X_6921_ clkload2/A _6921_/D VGND VGND VPWR VPWR _6921_/Q sky130_fd_sc_hd__dfxtp_2
XFILLER_81_158 VGND VGND VPWR VPWR sky130_fd_sc_hd__fill_2
XFILLER_81_169 VGND VGND VPWR VPWR sky130_fd_sc_hd__decap_3
X_6852_ _6965_/CLK _6852_/D VGND VGND VPWR VPWR _6852_/Q sky130_fd_sc_hd__dfxtp_2
XFILLER_22_203 VGND VGND VPWR VPWR sky130_fd_sc_hd__decap_3
XFILLER_22_214 VGND VGND VPWR VPWR sky130_fd_sc_hd__decap_3
XFILLER_50_512 VGND VGND VPWR VPWR sky130_fd_sc_hd__fill_2
XFILLER_90_681 VGND VGND VPWR VPWR sky130_fd_sc_hd__decap_3
Xfanout18 _6540_/A VGND VGND VPWR VPWR _6539_/A sky130_fd_sc_hd__buf_2
Xfanout29 _6536_/A VGND VGND VPWR VPWR _6600_/A sky130_fd_sc_hd__clkdlybuf4s25_1
XFILLER_50_556 VGND VGND VPWR VPWR sky130_fd_sc_hd__decap_3
X_6783_ _7383_/CLK _6783_/D VGND VGND VPWR VPWR _6783_/Q sky130_fd_sc_hd__dfxtp_2
XFILLER_10_409 VGND VGND VPWR VPWR sky130_fd_sc_hd__fill_2
XFILLER_13_17 VGND VGND VPWR VPWR sky130_fd_sc_hd__decap_3
X_5665_ _5665_/A _5665_/B _5665_/C _5665_/D VGND VGND VPWR VPWR _5666_/B sky130_fd_sc_hd__and4_2
XTAP_TAPCELL_ROW_79_1203 VGND VPWR sky130_fd_sc_hd__tapvpwrvgnd_1
X_7404_ _7406_/CLK _7404_/D _6684_/Y VGND VGND VPWR VPWR _7404_/Q sky130_fd_sc_hd__dfrtp_2
X_4616_ _3547_/A _3547_/B _4614_/X _4615_/Y VGND VGND VPWR VPWR _4617_/C sky130_fd_sc_hd__a31o_2
XFILLER_116_330 VGND VGND VPWR VPWR sky130_fd_sc_hd__decap_3
X_7335_ _7372_/CLK _7335_/D _6615_/Y VGND VGND VPWR VPWR _7335_/Q sky130_fd_sc_hd__dfrtp_2
XPHY_EDGE_ROW_111_Right_111 VGND VGND VPWR VPWR sky130_fd_sc_hd__decap_3
XFILLER_104_547 VGND VGND VPWR VPWR sky130_fd_sc_hd__fill_2
XFILLER_116_385 VGND VGND VPWR VPWR sky130_fd_sc_hd__decap_3
XFILLER_116_396 VGND VGND VPWR VPWR sky130_fd_sc_hd__decap_3
XFILLER_89_214 VGND VGND VPWR VPWR sky130_fd_sc_hd__decap_3
XFILLER_89_225 VGND VGND VPWR VPWR sky130_fd_sc_hd__decap_3
X_7266_ _7266_/CLK _7266_/D _6546_/Y VGND VGND VPWR VPWR _7266_/Q sky130_fd_sc_hd__dfrtp_2
X_4478_ _4478_/A0 _4544_/A _4488_/S VGND VGND VPWR VPWR _7340_/D sky130_fd_sc_hd__mux2_2
XFILLER_58_601 VGND VGND VPWR VPWR sky130_fd_sc_hd__decap_3
XFILLER_89_269 VGND VGND VPWR VPWR sky130_fd_sc_hd__fill_2
X_7197_ _7360_/CLK _7197_/D _6477_/Y VGND VGND VPWR VPWR _7197_/Q sky130_fd_sc_hd__dfrtp_2
X_3429_ _3429_/A _3429_/B VGND VGND VPWR VPWR _3590_/A sky130_fd_sc_hd__or2_2
XFILLER_38_36 VGND VGND VPWR VPWR sky130_fd_sc_hd__decap_3
XFILLER_57_100 VGND VGND VPWR VPWR sky130_fd_sc_hd__decap_3
XFILLER_58_634 VGND VGND VPWR VPWR sky130_fd_sc_hd__decap_3
XFILLER_38_69 VGND VGND VPWR VPWR sky130_fd_sc_hd__fill_2
XFILLER_57_144 VGND VGND VPWR VPWR sky130_fd_sc_hd__decap_3
XFILLER_58_645 VGND VGND VPWR VPWR sky130_fd_sc_hd__decap_3
Xhold1110 _4482_/X VGND VGND VPWR VPWR _7338_/D sky130_fd_sc_hd__dlygate4sd3_1
Xhold1121 _7330_/Q VGND VGND VPWR VPWR _4499_/A0 sky130_fd_sc_hd__dlygate4sd3_1
Xhold1132 _7336_/Q VGND VGND VPWR VPWR _4486_/A0 sky130_fd_sc_hd__dlygate4sd3_1
XFILLER_58_678 VGND VGND VPWR VPWR sky130_fd_sc_hd__decap_3
XFILLER_73_626 VGND VGND VPWR VPWR sky130_fd_sc_hd__decap_3
Xhold1143 _7171_/Q VGND VGND VPWR VPWR _5319_/A0 sky130_fd_sc_hd__dlygate4sd3_1
Xhold1154 _7154_/Q VGND VGND VPWR VPWR _5354_/A0 sky130_fd_sc_hd__dlygate4sd3_1
Xhold1165 _7142_/Q VGND VGND VPWR VPWR _5381_/A0 sky130_fd_sc_hd__dlygate4sd3_1
Xhold1176 _7180_/Q VGND VGND VPWR VPWR _5300_/A0 sky130_fd_sc_hd__dlygate4sd3_1
XFILLER_26_520 VGND VGND VPWR VPWR sky130_fd_sc_hd__decap_3
XFILLER_38_391 VGND VGND VPWR VPWR sky130_fd_sc_hd__decap_3
XFILLER_73_659 VGND VGND VPWR VPWR sky130_fd_sc_hd__decap_3
Xhold1187 _7121_/Q VGND VGND VPWR VPWR _5425_/A0 sky130_fd_sc_hd__dlygate4sd3_1
Xhold1198 _7156_/Q VGND VGND VPWR VPWR _5350_/A0 sky130_fd_sc_hd__dlygate4sd3_1
XFILLER_26_553 VGND VGND VPWR VPWR sky130_fd_sc_hd__decap_3
XFILLER_54_24 VGND VGND VPWR VPWR sky130_fd_sc_hd__decap_3
XFILLER_60_309 VGND VGND VPWR VPWR sky130_fd_sc_hd__decap_3
XFILLER_13_214 VGND VGND VPWR VPWR sky130_fd_sc_hd__fill_2
XFILLER_13_225 VGND VGND VPWR VPWR sky130_fd_sc_hd__decap_3
XFILLER_54_68 VGND VGND VPWR VPWR sky130_fd_sc_hd__decap_3
XFILLER_110_41 VGND VGND VPWR VPWR sky130_fd_sc_hd__decap_3
XFILLER_41_545 VGND VGND VPWR VPWR sky130_fd_sc_hd__decap_3
XFILLER_41_567 VGND VGND VPWR VPWR sky130_fd_sc_hd__decap_3
XFILLER_110_74 VGND VGND VPWR VPWR sky130_fd_sc_hd__decap_3
XFILLER_110_85 VGND VGND VPWR VPWR sky130_fd_sc_hd__decap_3
XFILLER_70_12 VGND VGND VPWR VPWR sky130_fd_sc_hd__decap_3
XFILLER_70_67 VGND VGND VPWR VPWR sky130_fd_sc_hd__decap_3
XFILLER_5_402 VGND VGND VPWR VPWR sky130_fd_sc_hd__decap_3
XFILLER_107_330 VGND VGND VPWR VPWR sky130_fd_sc_hd__decap_3
XFILLER_5_435 VGND VGND VPWR VPWR sky130_fd_sc_hd__decap_3
XFILLER_5_479 VGND VGND VPWR VPWR sky130_fd_sc_hd__decap_3
XFILLER_79_32 VGND VGND VPWR VPWR sky130_fd_sc_hd__fill_2
XFILLER_79_87 VGND VGND VPWR VPWR sky130_fd_sc_hd__decap_3
XFILLER_1_652 VGND VGND VPWR VPWR sky130_fd_sc_hd__decap_3
XFILLER_49_612 VGND VGND VPWR VPWR sky130_fd_sc_hd__decap_3
XFILLER_49_623 VGND VGND VPWR VPWR sky130_fd_sc_hd__decap_3
XFILLER_95_228 VGND VGND VPWR VPWR sky130_fd_sc_hd__decap_3
XFILLER_0_195 VGND VGND VPWR VPWR sky130_fd_sc_hd__fill_1
XFILLER_103_591 VGND VGND VPWR VPWR sky130_fd_sc_hd__fill_2
XFILLER_48_111 VGND VGND VPWR VPWR sky130_fd_sc_hd__decap_3
XFILLER_48_144 VGND VGND VPWR VPWR sky130_fd_sc_hd__fill_1
XFILLER_49_656 VGND VGND VPWR VPWR sky130_fd_sc_hd__decap_3
XFILLER_76_442 VGND VGND VPWR VPWR sky130_fd_sc_hd__decap_3
XFILLER_48_166 VGND VGND VPWR VPWR sky130_fd_sc_hd__decap_3
XFILLER_48_177 VGND VGND VPWR VPWR sky130_fd_sc_hd__decap_3
XFILLER_64_604 VGND VGND VPWR VPWR sky130_fd_sc_hd__decap_3
XFILLER_91_412 VGND VGND VPWR VPWR sky130_fd_sc_hd__decap_3
XFILLER_95_86 VGND VGND VPWR VPWR sky130_fd_sc_hd__decap_3
XTAP_TAPCELL_ROW_47_813 VGND VPWR sky130_fd_sc_hd__tapvpwrvgnd_1
XFILLER_63_125 VGND VGND VPWR VPWR sky130_fd_sc_hd__decap_3
XFILLER_64_637 VGND VGND VPWR VPWR sky130_fd_sc_hd__decap_3
XFILLER_64_648 VGND VGND VPWR VPWR sky130_fd_sc_hd__decap_3
XFILLER_17_564 VGND VGND VPWR VPWR sky130_fd_sc_hd__decap_3
XFILLER_44_350 VGND VGND VPWR VPWR sky130_fd_sc_hd__fill_1
XFILLER_63_158 VGND VGND VPWR VPWR sky130_fd_sc_hd__decap_3
XFILLER_63_169 VGND VGND VPWR VPWR sky130_fd_sc_hd__fill_1
XFILLER_32_501 VGND VGND VPWR VPWR sky130_fd_sc_hd__decap_3
XFILLER_72_681 VGND VGND VPWR VPWR sky130_fd_sc_hd__decap_3
XTAP_TAPCELL_ROW_63_1004 VGND VPWR sky130_fd_sc_hd__tapvpwrvgnd_1
XTAP_TAPCELL_ROW_27_570 VGND VPWR sky130_fd_sc_hd__tapvpwrvgnd_1
XTAP_TAPCELL_ROW_27_581 VGND VPWR sky130_fd_sc_hd__tapvpwrvgnd_1
XFILLER_32_589 VGND VGND VPWR VPWR sky130_fd_sc_hd__decap_3
X_3780_ _6967_/Q _3886_/A2 _3886_/B1 _6955_/Q VGND VGND VPWR VPWR _3780_/X sky130_fd_sc_hd__a22o_2
XFILLER_12_280 VGND VGND VPWR VPWR sky130_fd_sc_hd__decap_3
XFILLER_67_3 VGND VGND VPWR VPWR sky130_fd_sc_hd__decap_3
X_4401_ _7274_/Q _4422_/A2 _4430_/A2 _7242_/Q _4400_/X VGND VGND VPWR VPWR _4401_/X
+ sky130_fd_sc_hd__a221o_2
Xoutput526 _6990_/Q VGND VGND VPWR VPWR pc_out[13] sky130_fd_sc_hd__clkdlybuf4s25_1
Xoutput515 _5640_/A VGND VGND VPWR VPWR instruction_out[3] sky130_fd_sc_hd__clkdlybuf4s25_1
Xoutput504 _3421_/B VGND VGND VPWR VPWR instruction_out[20] sky130_fd_sc_hd__clkdlybuf4s25_1
X_5381_ _5381_/A0 _4864_/X _5386_/S VGND VGND VPWR VPWR _7142_/D sky130_fd_sc_hd__mux2_2
XFILLER_5_51 VGND VGND VPWR VPWR sky130_fd_sc_hd__decap_3
X_7120_ _7312_/CLK _7120_/D _6400_/Y VGND VGND VPWR VPWR _7120_/Q sky130_fd_sc_hd__dfrtp_2
Xoutput548 _6981_/Q VGND VGND VPWR VPWR pc_out[4] sky130_fd_sc_hd__clkdlybuf4s25_1
Xoutput537 _7000_/Q VGND VGND VPWR VPWR pc_out[23] sky130_fd_sc_hd__clkdlybuf4s25_1
X_4332_ _7191_/Q _4471_/S _4332_/B1 _7383_/Q _4331_/X VGND VGND VPWR VPWR _4332_/X
+ sky130_fd_sc_hd__a221o_2
XTAP_TAPCELL_ROW_74_1144 VGND VPWR sky130_fd_sc_hd__tapvpwrvgnd_1
XFILLER_99_545 VGND VGND VPWR VPWR sky130_fd_sc_hd__decap_3
XFILLER_59_409 VGND VGND VPWR VPWR sky130_fd_sc_hd__fill_2
XFILLER_5_84 VGND VGND VPWR VPWR sky130_fd_sc_hd__decap_3
X_7051_ _7402_/CLK _7051_/D _6331_/Y VGND VGND VPWR VPWR _7051_/Q sky130_fd_sc_hd__dfrtp_2
X_4263_ _7134_/Q _4348_/B1 _4261_/X _4262_/X VGND VGND VPWR VPWR _4264_/B sky130_fd_sc_hd__a211o_2
XFILLER_113_377 VGND VGND VPWR VPWR sky130_fd_sc_hd__decap_3
XFILLER_113_399 VGND VGND VPWR VPWR sky130_fd_sc_hd__fill_1
XFILLER_39_100 VGND VGND VPWR VPWR sky130_fd_sc_hd__fill_1
XFILLER_86_206 VGND VGND VPWR VPWR sky130_fd_sc_hd__decap_3
XFILLER_86_228 VGND VGND VPWR VPWR sky130_fd_sc_hd__decap_3
XPHY_EDGE_ROW_105_Left_222 VGND VGND VPWR VPWR sky130_fd_sc_hd__decap_3
XFILLER_99_589 VGND VGND VPWR VPWR sky130_fd_sc_hd__decap_3
XFILLER_39_111 VGND VGND VPWR VPWR sky130_fd_sc_hd__fill_1
X_4194_ _7231_/Q _3318_/B _4418_/A2 _7017_/Q _4193_/X VGND VGND VPWR VPWR _4194_/X
+ sky130_fd_sc_hd__a221o_2
XFILLER_27_317 VGND VGND VPWR VPWR sky130_fd_sc_hd__decap_3
XFILLER_39_166 VGND VGND VPWR VPWR sky130_fd_sc_hd__fill_2
XFILLER_55_615 VGND VGND VPWR VPWR sky130_fd_sc_hd__fill_1
XFILLER_55_626 VGND VGND VPWR VPWR sky130_fd_sc_hd__decap_3
XFILLER_67_475 VGND VGND VPWR VPWR sky130_fd_sc_hd__decap_3
XFILLER_54_103 VGND VGND VPWR VPWR sky130_fd_sc_hd__decap_3
XFILLER_55_659 VGND VGND VPWR VPWR sky130_fd_sc_hd__decap_3
XFILLER_94_283 VGND VGND VPWR VPWR sky130_fd_sc_hd__fill_2
XFILLER_42_309 VGND VGND VPWR VPWR sky130_fd_sc_hd__fill_1
XFILLER_54_147 VGND VGND VPWR VPWR sky130_fd_sc_hd__decap_3
XFILLER_70_607 VGND VGND VPWR VPWR sky130_fd_sc_hd__decap_3
X_6904_ _6944_/CLK _6904_/D VGND VGND VPWR VPWR _6904_/Q sky130_fd_sc_hd__dfxtp_2
XFILLER_35_361 VGND VGND VPWR VPWR sky130_fd_sc_hd__decap_3
XTAP_TAPCELL_ROW_85_1273 VGND VPWR sky130_fd_sc_hd__tapvpwrvgnd_1
XFILLER_50_320 VGND VGND VPWR VPWR sky130_fd_sc_hd__decap_3
X_6835_ _6975_/CLK _6835_/D VGND VGND VPWR VPWR _6835_/Q sky130_fd_sc_hd__dfxtp_2
XFILLER_10_206 VGND VGND VPWR VPWR sky130_fd_sc_hd__decap_3
XFILLER_23_567 VGND VGND VPWR VPWR sky130_fd_sc_hd__decap_3
X_6766_ _6965_/CLK _6766_/D VGND VGND VPWR VPWR _6766_/Q sky130_fd_sc_hd__dfxtp_2
XPHY_EDGE_ROW_114_Left_231 VGND VGND VPWR VPWR sky130_fd_sc_hd__decap_3
XFILLER_109_606 VGND VGND VPWR VPWR sky130_fd_sc_hd__decap_3
X_5717_ _7364_/Q hold918/X _5737_/S VGND VGND VPWR VPWR _6708_/D sky130_fd_sc_hd__mux2_2
XFILLER_109_617 VGND VGND VPWR VPWR sky130_fd_sc_hd__decap_3
XFILLER_40_15 VGND VGND VPWR VPWR sky130_fd_sc_hd__decap_3
X_6697_ _7386_/CLK _6697_/D VGND VGND VPWR VPWR _6697_/Q sky130_fd_sc_hd__dfxtp_2
XFILLER_108_127 VGND VGND VPWR VPWR sky130_fd_sc_hd__decap_3
X_5648_ _5648_/A _5648_/B VGND VGND VPWR VPWR _5649_/A sky130_fd_sc_hd__or2_2
X_5579_ _5579_/A0 _5045_/X _5581_/S VGND VGND VPWR VPWR _7039_/D sky130_fd_sc_hd__mux2_2
XFILLER_2_416 VGND VGND VPWR VPWR sky130_fd_sc_hd__decap_3
XFILLER_2_427 VGND VGND VPWR VPWR sky130_fd_sc_hd__decap_3
X_7318_ clkload3/A _7318_/D _6598_/Y VGND VGND VPWR VPWR _7318_/Q sky130_fd_sc_hd__dfrtp_2
XFILLER_104_333 VGND VGND VPWR VPWR sky130_fd_sc_hd__decap_3
XFILLER_104_355 VGND VGND VPWR VPWR sky130_fd_sc_hd__decap_3
XFILLER_116_193 VGND VGND VPWR VPWR sky130_fd_sc_hd__decap_3
XFILLER_49_24 VGND VGND VPWR VPWR sky130_fd_sc_hd__decap_3
X_7249_ _7312_/CLK _7249_/D _6529_/Y VGND VGND VPWR VPWR _7249_/Q sky130_fd_sc_hd__dfrtp_2
XFILLER_104_377 VGND VGND VPWR VPWR sky130_fd_sc_hd__decap_3
XFILLER_49_57 VGND VGND VPWR VPWR sky130_fd_sc_hd__fill_1
XFILLER_77_228 VGND VGND VPWR VPWR sky130_fd_sc_hd__decap_3
XFILLER_105_30 VGND VGND VPWR VPWR sky130_fd_sc_hd__decap_3
XFILLER_18_306 VGND VGND VPWR VPWR sky130_fd_sc_hd__fill_2
XFILLER_46_626 VGND VGND VPWR VPWR sky130_fd_sc_hd__decap_3
XFILLER_58_475 VGND VGND VPWR VPWR sky130_fd_sc_hd__fill_1
XFILLER_65_12 VGND VGND VPWR VPWR sky130_fd_sc_hd__decap_3
XFILLER_18_339 VGND VGND VPWR VPWR sky130_fd_sc_hd__decap_3
XFILLER_46_648 VGND VGND VPWR VPWR sky130_fd_sc_hd__decap_3
XFILLER_45_169 VGND VGND VPWR VPWR sky130_fd_sc_hd__decap_3
XFILLER_65_78 VGND VGND VPWR VPWR sky130_fd_sc_hd__decap_3
XFILLER_73_456 VGND VGND VPWR VPWR sky130_fd_sc_hd__decap_3
XFILLER_14_501 VGND VGND VPWR VPWR sky130_fd_sc_hd__decap_3
XFILLER_54_681 VGND VGND VPWR VPWR sky130_fd_sc_hd__decap_3
XFILLER_60_117 VGND VGND VPWR VPWR sky130_fd_sc_hd__decap_3
XFILLER_61_629 VGND VGND VPWR VPWR sky130_fd_sc_hd__decap_3
XFILLER_73_489 VGND VGND VPWR VPWR sky130_fd_sc_hd__decap_3
XFILLER_26_394 VGND VGND VPWR VPWR sky130_fd_sc_hd__decap_3
XFILLER_14_589 VGND VGND VPWR VPWR sky130_fd_sc_hd__decap_3
XTAP_TAPCELL_ROW_52_871 VGND VPWR sky130_fd_sc_hd__tapvpwrvgnd_1
XTAP_TAPCELL_ROW_24_540 VGND VPWR sky130_fd_sc_hd__tapvpwrvgnd_1
XFILLER_14_71 VGND VGND VPWR VPWR sky130_fd_sc_hd__decap_3
XFILLER_14_93 VGND VGND VPWR VPWR sky130_fd_sc_hd__fill_1
XFILLER_108_672 VGND VGND VPWR VPWR sky130_fd_sc_hd__decap_3
XFILLER_115_609 VGND VGND VPWR VPWR sky130_fd_sc_hd__decap_3
XFILLER_53_9 VGND VGND VPWR VPWR sky130_fd_sc_hd__decap_3
XFILLER_5_243 VGND VGND VPWR VPWR sky130_fd_sc_hd__decap_3
XFILLER_5_265 VGND VGND VPWR VPWR sky130_fd_sc_hd__decap_3
XFILLER_107_193 VGND VGND VPWR VPWR sky130_fd_sc_hd__decap_3
XFILLER_68_206 VGND VGND VPWR VPWR sky130_fd_sc_hd__decap_3
XFILLER_68_217 VGND VGND VPWR VPWR sky130_fd_sc_hd__decap_3
XFILLER_96_515 VGND VGND VPWR VPWR sky130_fd_sc_hd__fill_2
XFILLER_110_347 VGND VGND VPWR VPWR sky130_fd_sc_hd__decap_3
XFILLER_49_431 VGND VGND VPWR VPWR sky130_fd_sc_hd__decap_3
XFILLER_68_239 VGND VGND VPWR VPWR sky130_fd_sc_hd__decap_3
XFILLER_96_548 VGND VGND VPWR VPWR sky130_fd_sc_hd__decap_3
XFILLER_37_615 VGND VGND VPWR VPWR sky130_fd_sc_hd__fill_1
XFILLER_49_464 VGND VGND VPWR VPWR sky130_fd_sc_hd__fill_2
XFILLER_36_125 VGND VGND VPWR VPWR sky130_fd_sc_hd__decap_3
XFILLER_24_309 VGND VGND VPWR VPWR sky130_fd_sc_hd__fill_2
XFILLER_36_158 VGND VGND VPWR VPWR sky130_fd_sc_hd__decap_3
XFILLER_52_607 VGND VGND VPWR VPWR sky130_fd_sc_hd__decap_3
XFILLER_91_242 VGND VGND VPWR VPWR sky130_fd_sc_hd__decap_3
XTAP_TAPCELL_ROW_108_1549 VGND VPWR sky130_fd_sc_hd__tapvpwrvgnd_1
XFILLER_45_670 VGND VGND VPWR VPWR sky130_fd_sc_hd__fill_2
X_4950_ _4950_/A _4950_/B VGND VGND VPWR VPWR _4950_/Y sky130_fd_sc_hd__nor2_2
XFILLER_44_180 VGND VGND VPWR VPWR sky130_fd_sc_hd__decap_3
XFILLER_60_640 VGND VGND VPWR VPWR sky130_fd_sc_hd__decap_3
X_4881_ _6998_/Q _4912_/A VGND VGND VPWR VPWR _4882_/B sky130_fd_sc_hd__or2_2
X_3901_ _3901_/A1 _5104_/A _3900_/Y VGND VGND VPWR VPWR _7381_/D sky130_fd_sc_hd__a21bo_2
XFILLER_60_651 VGND VGND VPWR VPWR sky130_fd_sc_hd__decap_3
XFILLER_60_684 VGND VGND VPWR VPWR sky130_fd_sc_hd__decap_3
X_6620_ _6651_/A VGND VGND VPWR VPWR _6620_/Y sky130_fd_sc_hd__inv_2
X_3832_ _3728_/Y _3824_/X _3826_/X _3735_/X _3831_/X VGND VGND VPWR VPWR _3832_/X
+ sky130_fd_sc_hd__a221o_2
X_6551_ _6617_/A VGND VGND VPWR VPWR _6551_/Y sky130_fd_sc_hd__inv_2
X_3763_ hold997/X _4791_/A1 _3762_/X VGND VGND VPWR VPWR _7395_/D sky130_fd_sc_hd__a21o_2
X_6482_ _6611_/A VGND VGND VPWR VPWR _6482_/Y sky130_fd_sc_hd__inv_2
XFILLER_9_593 VGND VGND VPWR VPWR sky130_fd_sc_hd__fill_2
XFILLER_106_609 VGND VGND VPWR VPWR sky130_fd_sc_hd__decap_3
XFILLER_10_18 VGND VGND VPWR VPWR sky130_fd_sc_hd__decap_3
XFILLER_10_29 VGND VGND VPWR VPWR sky130_fd_sc_hd__decap_3
XFILLER_114_631 VGND VGND VPWR VPWR sky130_fd_sc_hd__decap_3
X_7103_ _7266_/CLK _7103_/D _6383_/Y VGND VGND VPWR VPWR _7103_/Q sky130_fd_sc_hd__dfrtp_2
X_4315_ _4315_/A _4315_/B VGND VGND VPWR VPWR _4361_/A sky130_fd_sc_hd__nand2_2
XFILLER_99_353 VGND VGND VPWR VPWR sky130_fd_sc_hd__fill_1
XFILLER_99_331 VGND VGND VPWR VPWR sky130_fd_sc_hd__decap_3
XFILLER_113_152 VGND VGND VPWR VPWR sky130_fd_sc_hd__decap_3
XFILLER_114_675 VGND VGND VPWR VPWR sky130_fd_sc_hd__decap_3
XFILLER_59_228 VGND VGND VPWR VPWR sky130_fd_sc_hd__fill_2
XFILLER_99_375 VGND VGND VPWR VPWR sky130_fd_sc_hd__decap_3
XFILLER_101_325 VGND VGND VPWR VPWR sky130_fd_sc_hd__decap_3
XFILLER_113_196 VGND VGND VPWR VPWR sky130_fd_sc_hd__decap_3
XFILLER_19_38 VGND VGND VPWR VPWR sky130_fd_sc_hd__decap_3
X_7034_ clkload9/A _7034_/D _6314_/Y VGND VGND VPWR VPWR _7034_/Q sky130_fd_sc_hd__dfrtp_2
X_4246_ _7229_/Q _4262_/A2 _4348_/B1 _7133_/Q VGND VGND VPWR VPWR _4246_/X sky130_fd_sc_hd__a22o_2
XFILLER_101_358 VGND VGND VPWR VPWR sky130_fd_sc_hd__decap_3
X_4177_ _7232_/Q _4262_/A2 _4175_/X _4176_/X VGND VGND VPWR VPWR _4177_/X sky130_fd_sc_hd__a211o_2
XFILLER_27_125 VGND VGND VPWR VPWR sky130_fd_sc_hd__decap_3
XFILLER_28_648 VGND VGND VPWR VPWR sky130_fd_sc_hd__decap_3
XFILLER_82_253 VGND VGND VPWR VPWR sky130_fd_sc_hd__decap_3
XTAP_TAPCELL_ROW_2_279 VGND VPWR sky130_fd_sc_hd__tapvpwrvgnd_1
XFILLER_27_169 VGND VGND VPWR VPWR sky130_fd_sc_hd__fill_2
XFILLER_70_404 VGND VGND VPWR VPWR sky130_fd_sc_hd__decap_3
XFILLER_70_415 VGND VGND VPWR VPWR sky130_fd_sc_hd__decap_3
XFILLER_70_448 VGND VGND VPWR VPWR sky130_fd_sc_hd__decap_3
XFILLER_70_459 VGND VGND VPWR VPWR sky130_fd_sc_hd__decap_3
XFILLER_23_353 VGND VGND VPWR VPWR sky130_fd_sc_hd__decap_3
XFILLER_51_662 VGND VGND VPWR VPWR sky130_fd_sc_hd__decap_3
XFILLER_51_673 VGND VGND VPWR VPWR sky130_fd_sc_hd__decap_3
X_6818_ _6909_/CLK _6818_/D VGND VGND VPWR VPWR _6818_/Q sky130_fd_sc_hd__dfxtp_2
XFILLER_50_161 VGND VGND VPWR VPWR sky130_fd_sc_hd__decap_3
XFILLER_50_194 VGND VGND VPWR VPWR sky130_fd_sc_hd__fill_2
XFILLER_51_36 VGND VGND VPWR VPWR sky130_fd_sc_hd__decap_3
XFILLER_109_414 VGND VGND VPWR VPWR sky130_fd_sc_hd__decap_3
XFILLER_51_69 VGND VGND VPWR VPWR sky130_fd_sc_hd__decap_3
X_6749_ _6965_/CLK _6749_/D VGND VGND VPWR VPWR _6749_/Q sky130_fd_sc_hd__dfxtp_2
XTAP_TAPCELL_ROW_98_1431 VGND VPWR sky130_fd_sc_hd__tapvpwrvgnd_1
XFILLER_105_620 VGND VGND VPWR VPWR sky130_fd_sc_hd__decap_3
XFILLER_105_653 VGND VGND VPWR VPWR sky130_fd_sc_hd__decap_3
XFILLER_104_141 VGND VGND VPWR VPWR sky130_fd_sc_hd__decap_3
XFILLER_100_380 VGND VGND VPWR VPWR sky130_fd_sc_hd__decap_3
XFILLER_58_261 VGND VGND VPWR VPWR sky130_fd_sc_hd__decap_3
XFILLER_76_77 VGND VGND VPWR VPWR sky130_fd_sc_hd__decap_3
XFILLER_76_88 VGND VGND VPWR VPWR sky130_fd_sc_hd__fill_1
XFILLER_86_592 VGND VGND VPWR VPWR sky130_fd_sc_hd__fill_2
XTAP_TAPCELL_ROW_57_930 VGND VPWR sky130_fd_sc_hd__tapvpwrvgnd_1
XFILLER_19_659 VGND VGND VPWR VPWR sky130_fd_sc_hd__decap_3
XTAP_TAPCELL_ROW_57_941 VGND VPWR sky130_fd_sc_hd__tapvpwrvgnd_1
XFILLER_26_191 VGND VGND VPWR VPWR sky130_fd_sc_hd__decap_3
XFILLER_33_128 VGND VGND VPWR VPWR sky130_fd_sc_hd__decap_3
XFILLER_25_81 VGND VGND VPWR VPWR sky130_fd_sc_hd__decap_3
XFILLER_42_662 VGND VGND VPWR VPWR sky130_fd_sc_hd__decap_3
XFILLER_41_172 VGND VGND VPWR VPWR sky130_fd_sc_hd__fill_2
XFILLER_41_183 VGND VGND VPWR VPWR sky130_fd_sc_hd__decap_3
XFILLER_6_530 VGND VGND VPWR VPWR sky130_fd_sc_hd__fill_2
XFILLER_51_6 VGND VGND VPWR VPWR sky130_fd_sc_hd__decap_3
XTAP_TAPCELL_ROW_71_1103 VGND VPWR sky130_fd_sc_hd__tapvpwrvgnd_1
XFILLER_111_612 VGND VGND VPWR VPWR sky130_fd_sc_hd__decap_3
XFILLER_110_100 VGND VGND VPWR VPWR sky130_fd_sc_hd__decap_3
XFILLER_111_623 VGND VGND VPWR VPWR sky130_fd_sc_hd__decap_3
XFILLER_111_656 VGND VGND VPWR VPWR sky130_fd_sc_hd__decap_3
X_5080_ _5080_/A0 _5079_/X _5136_/S VGND VGND VPWR VPWR _7257_/D sky130_fd_sc_hd__mux2_2
X_4100_ _7269_/Q _4422_/A2 _4430_/A2 _7237_/Q _4099_/X VGND VGND VPWR VPWR _4100_/X
+ sky130_fd_sc_hd__a221o_2
XFILLER_110_133 VGND VGND VPWR VPWR sky130_fd_sc_hd__decap_3
XFILLER_110_144 VGND VGND VPWR VPWR sky130_fd_sc_hd__decap_3
XFILLER_2_41 VGND VGND VPWR VPWR sky130_fd_sc_hd__decap_3
XFILLER_84_529 VGND VGND VPWR VPWR sky130_fd_sc_hd__decap_3
XFILLER_96_356 VGND VGND VPWR VPWR sky130_fd_sc_hd__decap_3
XFILLER_110_177 VGND VGND VPWR VPWR sky130_fd_sc_hd__decap_3
XFILLER_2_74 VGND VGND VPWR VPWR sky130_fd_sc_hd__decap_3
XFILLER_2_85 VGND VGND VPWR VPWR sky130_fd_sc_hd__decap_3
XFILLER_37_434 VGND VGND VPWR VPWR sky130_fd_sc_hd__fill_1
XFILLER_64_220 VGND VGND VPWR VPWR sky130_fd_sc_hd__decap_3
XFILLER_24_106 VGND VGND VPWR VPWR sky130_fd_sc_hd__decap_3
XFILLER_25_629 VGND VGND VPWR VPWR sky130_fd_sc_hd__fill_1
XFILLER_64_253 VGND VGND VPWR VPWR sky130_fd_sc_hd__decap_3
XFILLER_64_286 VGND VGND VPWR VPWR sky130_fd_sc_hd__decap_3
XFILLER_92_584 VGND VGND VPWR VPWR sky130_fd_sc_hd__decap_3
XTAP_TAPCELL_ROW_69_1076 VGND VPWR sky130_fd_sc_hd__tapvpwrvgnd_1
XFILLER_17_191 VGND VGND VPWR VPWR sky130_fd_sc_hd__decap_3
X_4933_ _4933_/A0 _4932_/X _4946_/S VGND VGND VPWR VPWR _7266_/D sky130_fd_sc_hd__mux2_2
XTAP_TAPCELL_ROW_82_1232 VGND VPWR sky130_fd_sc_hd__tapvpwrvgnd_1
XFILLER_33_662 VGND VGND VPWR VPWR sky130_fd_sc_hd__decap_3
XTAP_TAPCELL_ROW_35_668 VGND VPWR sky130_fd_sc_hd__tapvpwrvgnd_1
XFILLER_60_492 VGND VGND VPWR VPWR sky130_fd_sc_hd__decap_3
X_4864_ _5092_/C _4857_/X _4860_/Y _7000_/D _4997_/A1 VGND VGND VPWR VPWR _4864_/X
+ sky130_fd_sc_hd__a32o_2
XFILLER_32_194 VGND VGND VPWR VPWR sky130_fd_sc_hd__fill_2
X_6603_ _6632_/A VGND VGND VPWR VPWR _6603_/Y sky130_fd_sc_hd__inv_2
X_4795_ _4795_/A _4795_/B VGND VGND VPWR VPWR _4795_/X sky130_fd_sc_hd__xor2_2
X_3815_ _6928_/Q _3926_/A2 _3925_/A2 _6702_/Q VGND VGND VPWR VPWR _3815_/X sky130_fd_sc_hd__a22o_2
XFILLER_20_389 VGND VGND VPWR VPWR sky130_fd_sc_hd__fill_1
X_6534_ _6568_/A VGND VGND VPWR VPWR _6534_/Y sky130_fd_sc_hd__inv_2
X_3746_ _3746_/A _3746_/B _3746_/C VGND VGND VPWR VPWR _3746_/X sky130_fd_sc_hd__and3_2
X_6465_ _6660_/A VGND VGND VPWR VPWR _6465_/Y sky130_fd_sc_hd__inv_2
XFILLER_106_439 VGND VGND VPWR VPWR sky130_fd_sc_hd__decap_3
X_3677_ _6942_/Q VGND VGND VPWR VPWR _3677_/Y sky130_fd_sc_hd__inv_2
X_6396_ _6651_/A VGND VGND VPWR VPWR _6396_/Y sky130_fd_sc_hd__inv_2
XTAP_TAPCELL_ROW_93_1372 VGND VPWR sky130_fd_sc_hd__tapvpwrvgnd_1
XTAP_TAPCELL_ROW_7_338 VGND VPWR sky130_fd_sc_hd__tapvpwrvgnd_1
XFILLER_102_645 VGND VGND VPWR VPWR sky130_fd_sc_hd__decap_3
X_5278_ _5278_/A0 _5107_/X _5292_/S VGND VGND VPWR VPWR _7191_/D sky130_fd_sc_hd__mux2_2
XFILLER_102_678 VGND VGND VPWR VPWR sky130_fd_sc_hd__decap_3
X_7017_ _7266_/CLK _7017_/D _6297_/Y VGND VGND VPWR VPWR _7017_/Q sky130_fd_sc_hd__dfrtp_2
X_4229_ _7099_/Q _4351_/A2 _4351_/B1 _7131_/Q VGND VGND VPWR VPWR _4229_/X sky130_fd_sc_hd__a22o_2
XFILLER_46_14 VGND VGND VPWR VPWR sky130_fd_sc_hd__decap_3
XFILLER_68_592 VGND VGND VPWR VPWR sky130_fd_sc_hd__decap_3
XFILLER_87_389 VGND VGND VPWR VPWR sky130_fd_sc_hd__decap_3
XFILLER_16_607 VGND VGND VPWR VPWR sky130_fd_sc_hd__decap_3
XFILLER_28_456 VGND VGND VPWR VPWR sky130_fd_sc_hd__fill_1
XFILLER_55_242 VGND VGND VPWR VPWR sky130_fd_sc_hd__decap_3
XFILLER_15_106 VGND VGND VPWR VPWR sky130_fd_sc_hd__fill_1
XFILLER_83_595 VGND VGND VPWR VPWR sky130_fd_sc_hd__decap_3
XTAP_TAPCELL_ROW_54_900 VGND VPWR sky130_fd_sc_hd__tapvpwrvgnd_1
XFILLER_102_64 VGND VGND VPWR VPWR sky130_fd_sc_hd__decap_3
XFILLER_55_297 VGND VGND VPWR VPWR sky130_fd_sc_hd__fill_1
XFILLER_62_24 VGND VGND VPWR VPWR sky130_fd_sc_hd__decap_3
XFILLER_11_312 VGND VGND VPWR VPWR sky130_fd_sc_hd__fill_2
XFILLER_23_172 VGND VGND VPWR VPWR sky130_fd_sc_hd__decap_3
XFILLER_62_68 VGND VGND VPWR VPWR sky130_fd_sc_hd__decap_3
XFILLER_70_289 VGND VGND VPWR VPWR sky130_fd_sc_hd__fill_2
XFILLER_11_334 VGND VGND VPWR VPWR sky130_fd_sc_hd__fill_2
XFILLER_109_211 VGND VGND VPWR VPWR sky130_fd_sc_hd__fill_1
XFILLER_109_222 VGND VGND VPWR VPWR sky130_fd_sc_hd__fill_2
XFILLER_11_378 VGND VGND VPWR VPWR sky130_fd_sc_hd__decap_3
XFILLER_109_233 VGND VGND VPWR VPWR sky130_fd_sc_hd__fill_2
XFILLER_109_255 VGND VGND VPWR VPWR sky130_fd_sc_hd__decap_3
XFILLER_7_349 VGND VGND VPWR VPWR sky130_fd_sc_hd__decap_3
XFILLER_11_72 VGND VGND VPWR VPWR sky130_fd_sc_hd__decap_3
XFILLER_105_461 VGND VGND VPWR VPWR sky130_fd_sc_hd__fill_1
XFILLER_87_21 VGND VGND VPWR VPWR sky130_fd_sc_hd__decap_3
XFILLER_97_109 VGND VGND VPWR VPWR sky130_fd_sc_hd__decap_3
XFILLER_105_483 VGND VGND VPWR VPWR sky130_fd_sc_hd__fill_1
XFILLER_78_312 VGND VGND VPWR VPWR sky130_fd_sc_hd__decap_3
XFILLER_78_356 VGND VGND VPWR VPWR sky130_fd_sc_hd__decap_3
XFILLER_87_98 VGND VGND VPWR VPWR sky130_fd_sc_hd__decap_3
XFILLER_16_9 VGND VGND VPWR VPWR sky130_fd_sc_hd__decap_3
XFILLER_59_581 VGND VGND VPWR VPWR sky130_fd_sc_hd__decap_3
XFILLER_93_337 VGND VGND VPWR VPWR sky130_fd_sc_hd__decap_3
XFILLER_19_445 VGND VGND VPWR VPWR sky130_fd_sc_hd__decap_3
XFILLER_46_242 VGND VGND VPWR VPWR sky130_fd_sc_hd__decap_3
XFILLER_93_359 VGND VGND VPWR VPWR sky130_fd_sc_hd__decap_3
XFILLER_46_253 VGND VGND VPWR VPWR sky130_fd_sc_hd__decap_3
XFILLER_74_562 VGND VGND VPWR VPWR sky130_fd_sc_hd__decap_3
XTAP_TAPCELL_ROW_105_1508 VGND VPWR sky130_fd_sc_hd__tapvpwrvgnd_1
XFILLER_61_223 VGND VGND VPWR VPWR sky130_fd_sc_hd__fill_1
XFILLER_74_595 VGND VGND VPWR VPWR sky130_fd_sc_hd__decap_3
XFILLER_61_278 VGND VGND VPWR VPWR sky130_fd_sc_hd__fill_2
XFILLER_30_632 VGND VGND VPWR VPWR sky130_fd_sc_hd__decap_3
XTAP_TAPCELL_ROW_32_638 VGND VPWR sky130_fd_sc_hd__tapvpwrvgnd_1
XFILLER_99_6 VGND VGND VPWR VPWR sky130_fd_sc_hd__decap_3
XFILLER_14_183 VGND VGND VPWR VPWR sky130_fd_sc_hd__decap_3
XTAP_TAPCELL_ROW_60_969 VGND VPWR sky130_fd_sc_hd__tapvpwrvgnd_1
X_3600_ _3600_/A VGND VGND VPWR VPWR _3600_/Y sky130_fd_sc_hd__inv_2
XTAP_TAPCELL_ROW_12_395 VGND VPWR sky130_fd_sc_hd__tapvpwrvgnd_1
XFILLER_115_214 VGND VGND VPWR VPWR sky130_fd_sc_hd__decap_3
XFILLER_6_360 VGND VGND VPWR VPWR sky130_fd_sc_hd__fill_1
Xhold806 _6849_/Q VGND VGND VPWR VPWR _6849_/D sky130_fd_sc_hd__dlygate4sd3_1
Xhold817 _6847_/Q VGND VGND VPWR VPWR _6847_/D sky130_fd_sc_hd__dlygate4sd3_1
Xhold828 _6961_/Q VGND VGND VPWR VPWR _6961_/D sky130_fd_sc_hd__dlygate4sd3_1
XTAP_TAPCELL_ROW_116_1648 VGND VPWR sky130_fd_sc_hd__tapvpwrvgnd_1
XFILLER_115_225 VGND VGND VPWR VPWR sky130_fd_sc_hd__decap_3
XFILLER_115_258 VGND VGND VPWR VPWR sky130_fd_sc_hd__decap_3
Xhold839 _6861_/Q VGND VGND VPWR VPWR _6861_/D sky130_fd_sc_hd__dlygate4sd3_1
Xmax_cap569 _3388_/Y VGND VGND VPWR VPWR _3556_/A sky130_fd_sc_hd__buf_2
Xmax_cap558 _5084_/B VGND VGND VPWR VPWR _5048_/A2 sky130_fd_sc_hd__clkdlybuf4s25_1
X_3462_ _7249_/Q _4601_/S _3459_/X _3461_/X VGND VGND VPWR VPWR _3462_/X sky130_fd_sc_hd__a211o_2
XTAP_TAPCELL_ROW_116_1659 VGND VPWR sky130_fd_sc_hd__tapvpwrvgnd_1
XFILLER_97_632 VGND VGND VPWR VPWR sky130_fd_sc_hd__decap_3
X_5132_ _5132_/A0 _5131_/X _5136_/S VGND VGND VPWR VPWR _7252_/D sky130_fd_sc_hd__mux2_2
XFILLER_96_153 VGND VGND VPWR VPWR sky130_fd_sc_hd__decap_3
XFILLER_97_676 VGND VGND VPWR VPWR sky130_fd_sc_hd__decap_3
XFILLER_97_665 VGND VGND VPWR VPWR sky130_fd_sc_hd__decap_3
XFILLER_96_197 VGND VGND VPWR VPWR sky130_fd_sc_hd__fill_1
X_5063_ _5063_/A0 _5061_/X _5136_/S VGND VGND VPWR VPWR _7258_/D sky130_fd_sc_hd__mux2_2
XFILLER_37_231 VGND VGND VPWR VPWR sky130_fd_sc_hd__fill_1
XFILLER_37_242 VGND VGND VPWR VPWR sky130_fd_sc_hd__decap_3
XFILLER_84_359 VGND VGND VPWR VPWR sky130_fd_sc_hd__decap_3
XFILLER_37_275 VGND VGND VPWR VPWR sky130_fd_sc_hd__decap_3
XFILLER_80_510 VGND VGND VPWR VPWR sky130_fd_sc_hd__decap_3
XFILLER_25_426 VGND VGND VPWR VPWR sky130_fd_sc_hd__decap_3
XFILLER_52_223 VGND VGND VPWR VPWR sky130_fd_sc_hd__decap_3
XFILLER_92_392 VGND VGND VPWR VPWR sky130_fd_sc_hd__decap_3
XFILLER_40_407 VGND VGND VPWR VPWR sky130_fd_sc_hd__decap_3
XFILLER_52_256 VGND VGND VPWR VPWR sky130_fd_sc_hd__decap_3
XFILLER_52_278 VGND VGND VPWR VPWR sky130_fd_sc_hd__fill_2
X_4916_ _4916_/A _4916_/B VGND VGND VPWR VPWR _4967_/A sky130_fd_sc_hd__nand2_2
XFILLER_20_120 VGND VGND VPWR VPWR sky130_fd_sc_hd__decap_3
XFILLER_32_16 VGND VGND VPWR VPWR sky130_fd_sc_hd__decap_3
X_4847_ _4968_/A _4384_/C _4206_/X VGND VGND VPWR VPWR _4904_/B sky130_fd_sc_hd__a21oi_2
XFILLER_32_49 VGND VGND VPWR VPWR sky130_fd_sc_hd__decap_3
XFILLER_20_197 VGND VGND VPWR VPWR sky130_fd_sc_hd__decap_3
X_4778_ _4778_/A _4778_/B VGND VGND VPWR VPWR _4827_/B sky130_fd_sc_hd__and2_2
XFILLER_106_203 VGND VGND VPWR VPWR sky130_fd_sc_hd__fill_1
XFILLER_4_319 VGND VGND VPWR VPWR sky130_fd_sc_hd__decap_3
X_6517_ _6642_/A VGND VGND VPWR VPWR _6517_/Y sky130_fd_sc_hd__inv_2
X_3729_ _6968_/Q _3879_/A2 _3888_/B1 _6962_/Q VGND VGND VPWR VPWR _3729_/X sky130_fd_sc_hd__a22o_2
XFILLER_106_225 VGND VGND VPWR VPWR sky130_fd_sc_hd__decap_3
X_6448_ _6608_/A VGND VGND VPWR VPWR _6448_/Y sky130_fd_sc_hd__inv_2
X_6379_ _6568_/A VGND VGND VPWR VPWR _6379_/Y sky130_fd_sc_hd__inv_2
XFILLER_0_536 VGND VGND VPWR VPWR sky130_fd_sc_hd__decap_3
XFILLER_114_280 VGND VGND VPWR VPWR sky130_fd_sc_hd__decap_3
XFILLER_88_632 VGND VGND VPWR VPWR sky130_fd_sc_hd__decap_3
XFILLER_102_442 VGND VGND VPWR VPWR sky130_fd_sc_hd__decap_3
XFILLER_87_131 VGND VGND VPWR VPWR sky130_fd_sc_hd__decap_3
XFILLER_88_654 VGND VGND VPWR VPWR sky130_fd_sc_hd__decap_3
XFILLER_57_46 VGND VGND VPWR VPWR sky130_fd_sc_hd__decap_3
XFILLER_57_57 VGND VGND VPWR VPWR sky130_fd_sc_hd__decap_3
XFILLER_75_326 VGND VGND VPWR VPWR sky130_fd_sc_hd__decap_3
XFILLER_75_337 VGND VGND VPWR VPWR sky130_fd_sc_hd__decap_3
XFILLER_87_175 VGND VGND VPWR VPWR sky130_fd_sc_hd__decap_3
XFILLER_113_30 VGND VGND VPWR VPWR sky130_fd_sc_hd__decap_3
XFILLER_28_231 VGND VGND VPWR VPWR sky130_fd_sc_hd__decap_3
XFILLER_113_63 VGND VGND VPWR VPWR sky130_fd_sc_hd__decap_3
XFILLER_16_404 VGND VGND VPWR VPWR sky130_fd_sc_hd__fill_2
XFILLER_28_253 VGND VGND VPWR VPWR sky130_fd_sc_hd__decap_3
XFILLER_43_201 VGND VGND VPWR VPWR sky130_fd_sc_hd__decap_3
XFILLER_56_584 VGND VGND VPWR VPWR sky130_fd_sc_hd__decap_3
XFILLER_73_12 VGND VGND VPWR VPWR sky130_fd_sc_hd__decap_3
XFILLER_90_307 VGND VGND VPWR VPWR sky130_fd_sc_hd__fill_1
XFILLER_113_96 VGND VGND VPWR VPWR sky130_fd_sc_hd__decap_3
XFILLER_28_286 VGND VGND VPWR VPWR sky130_fd_sc_hd__decap_3
XFILLER_56_595 VGND VGND VPWR VPWR sky130_fd_sc_hd__decap_3
XFILLER_71_532 VGND VGND VPWR VPWR sky130_fd_sc_hd__decap_3
XFILLER_43_267 VGND VGND VPWR VPWR sky130_fd_sc_hd__fill_2
XFILLER_71_576 VGND VGND VPWR VPWR sky130_fd_sc_hd__decap_3
XFILLER_73_78 VGND VGND VPWR VPWR sky130_fd_sc_hd__decap_3
XFILLER_31_429 VGND VGND VPWR VPWR sky130_fd_sc_hd__decap_3
XFILLER_71_598 VGND VGND VPWR VPWR sky130_fd_sc_hd__fill_2
XFILLER_11_131 VGND VGND VPWR VPWR sky130_fd_sc_hd__decap_3
XTAP_TAPCELL_ROW_100_1449 VGND VPWR sky130_fd_sc_hd__tapvpwrvgnd_1
XFILLER_11_164 VGND VGND VPWR VPWR sky130_fd_sc_hd__decap_3
XFILLER_12_665 VGND VGND VPWR VPWR sky130_fd_sc_hd__decap_3
XFILLER_7_102 VGND VGND VPWR VPWR sky130_fd_sc_hd__decap_3
XFILLER_7_113 VGND VGND VPWR VPWR sky130_fd_sc_hd__decap_3
XFILLER_7_146 VGND VGND VPWR VPWR sky130_fd_sc_hd__decap_3
XFILLER_98_53 VGND VGND VPWR VPWR sky130_fd_sc_hd__decap_3
XFILLER_112_206 VGND VGND VPWR VPWR sky130_fd_sc_hd__decap_3
XFILLER_98_418 VGND VGND VPWR VPWR sky130_fd_sc_hd__fill_2
XFILLER_3_396 VGND VGND VPWR VPWR sky130_fd_sc_hd__decap_3
XFILLER_79_632 VGND VGND VPWR VPWR sky130_fd_sc_hd__decap_3
XFILLER_78_153 VGND VGND VPWR VPWR sky130_fd_sc_hd__decap_3
XFILLER_79_665 VGND VGND VPWR VPWR sky130_fd_sc_hd__decap_3
XFILLER_79_676 VGND VGND VPWR VPWR sky130_fd_sc_hd__decap_3
XTAP_TAPCELL_ROW_111_1578 VGND VPWR sky130_fd_sc_hd__tapvpwrvgnd_1
XFILLER_94_624 VGND VGND VPWR VPWR sky130_fd_sc_hd__decap_3
XTAP_TAPCELL_ROW_111_1589 VGND VPWR sky130_fd_sc_hd__tapvpwrvgnd_1
XFILLER_14_6 VGND VGND VPWR VPWR sky130_fd_sc_hd__decap_3
XFILLER_47_540 VGND VGND VPWR VPWR sky130_fd_sc_hd__decap_3
XFILLER_66_359 VGND VGND VPWR VPWR sky130_fd_sc_hd__fill_1
XFILLER_78_197 VGND VGND VPWR VPWR sky130_fd_sc_hd__decap_3
XFILLER_94_657 VGND VGND VPWR VPWR sky130_fd_sc_hd__decap_3
XFILLER_19_242 VGND VGND VPWR VPWR sky130_fd_sc_hd__decap_3
XFILLER_81_329 VGND VGND VPWR VPWR sky130_fd_sc_hd__decap_3
XFILLER_34_212 VGND VGND VPWR VPWR sky130_fd_sc_hd__decap_3
XFILLER_34_234 VGND VGND VPWR VPWR sky130_fd_sc_hd__decap_3
XFILLER_62_521 VGND VGND VPWR VPWR sky130_fd_sc_hd__decap_3
XTAP_TAPCELL_ROW_66_1046 VGND VPWR sky130_fd_sc_hd__tapvpwrvgnd_1
XTAP_TAPCELL_ROW_17_454 VGND VPWR sky130_fd_sc_hd__tapvpwrvgnd_1
XFILLER_62_598 VGND VGND VPWR VPWR sky130_fd_sc_hd__decap_3
XFILLER_97_3 VGND VGND VPWR VPWR sky130_fd_sc_hd__decap_3
XTAP_TAPCELL_ROW_45_796 VGND VPWR sky130_fd_sc_hd__tapvpwrvgnd_1
X_4701_ _6989_/Q _6990_/Q _5044_/A VGND VGND VPWR VPWR _5026_/A sky130_fd_sc_hd__and3_2
XFILLER_30_473 VGND VGND VPWR VPWR sky130_fd_sc_hd__decap_3
X_4632_ _4626_/X _4274_/Y _4631_/X VGND VGND VPWR VPWR _4916_/B sky130_fd_sc_hd__a21oi_2
XFILLER_8_62 VGND VGND VPWR VPWR sky130_fd_sc_hd__decap_3
XFILLER_116_501 VGND VGND VPWR VPWR sky130_fd_sc_hd__decap_3
X_7351_ _7352_/CLK _7351_/D _6631_/Y VGND VGND VPWR VPWR _7351_/Q sky130_fd_sc_hd__dfrtp_2
Xhold603 _6934_/Q VGND VGND VPWR VPWR _6934_/D sky130_fd_sc_hd__dlygate4sd3_1
X_4563_ _4563_/A _4563_/B VGND VGND VPWR VPWR _7299_/D sky130_fd_sc_hd__and2_2
XFILLER_116_545 VGND VGND VPWR VPWR sky130_fd_sc_hd__decap_3
XFILLER_7_691 VGND VGND VPWR VPWR sky130_fd_sc_hd__fill_1
X_7282_ _7352_/CLK _7282_/D _6562_/Y VGND VGND VPWR VPWR _7282_/Q sky130_fd_sc_hd__dfrtp_2
Xhold614 _6784_/Q VGND VGND VPWR VPWR _6784_/D sky130_fd_sc_hd__dlygate4sd3_1
Xhold625 _6917_/Q VGND VGND VPWR VPWR _6917_/D sky130_fd_sc_hd__dlygate4sd3_1
Xhold636 _6918_/Q VGND VGND VPWR VPWR _6918_/D sky130_fd_sc_hd__dlygate4sd3_1
X_6302_ _6553_/A VGND VGND VPWR VPWR _6302_/Y sky130_fd_sc_hd__inv_2
XFILLER_116_589 VGND VGND VPWR VPWR sky130_fd_sc_hd__decap_3
Xhold647 _6876_/Q VGND VGND VPWR VPWR _6876_/D sky130_fd_sc_hd__dlygate4sd3_1
Xhold658 _6863_/Q VGND VGND VPWR VPWR _6863_/D sky130_fd_sc_hd__dlygate4sd3_1
Xhold669 _6775_/Q VGND VGND VPWR VPWR _6775_/D sky130_fd_sc_hd__dlygate4sd3_1
XTAP_TAPCELL_ROW_77_1175 VGND VPWR sky130_fd_sc_hd__tapvpwrvgnd_1
XTAP_TAPCELL_ROW_90_1331 VGND VPWR sky130_fd_sc_hd__tapvpwrvgnd_1
XFILLER_85_602 VGND VGND VPWR VPWR sky130_fd_sc_hd__decap_3
X_3376_ _3376_/A _3376_/B VGND VGND VPWR VPWR _3376_/Y sky130_fd_sc_hd__nor2_2
XFILLER_111_272 VGND VGND VPWR VPWR sky130_fd_sc_hd__decap_3
XFILLER_69_175 VGND VGND VPWR VPWR sky130_fd_sc_hd__decap_3
XFILLER_85_635 VGND VGND VPWR VPWR sky130_fd_sc_hd__decap_3
XFILLER_97_473 VGND VGND VPWR VPWR sky130_fd_sc_hd__decap_3
X_5115_ _5101_/A _4292_/C _5113_/Y _5020_/A _5114_/Y VGND VGND VPWR VPWR _5115_/X
+ sky130_fd_sc_hd__o221a_2
XFILLER_27_27 VGND VGND VPWR VPWR sky130_fd_sc_hd__decap_3
XFILLER_57_337 VGND VGND VPWR VPWR sky130_fd_sc_hd__decap_3
XFILLER_84_123 VGND VGND VPWR VPWR sky130_fd_sc_hd__decap_3
XFILLER_85_668 VGND VGND VPWR VPWR sky130_fd_sc_hd__decap_3
X_5046_ _5101_/B VGND VGND VPWR VPWR _5100_/A sky130_fd_sc_hd__inv_2
XFILLER_72_307 VGND VGND VPWR VPWR sky130_fd_sc_hd__fill_1
XFILLER_72_318 VGND VGND VPWR VPWR sky130_fd_sc_hd__decap_3
XFILLER_84_156 VGND VGND VPWR VPWR sky130_fd_sc_hd__fill_1
XFILLER_85_679 VGND VGND VPWR VPWR sky130_fd_sc_hd__decap_3
XFILLER_65_381 VGND VGND VPWR VPWR sky130_fd_sc_hd__decap_3
XFILLER_25_256 VGND VGND VPWR VPWR sky130_fd_sc_hd__decap_3
XFILLER_80_340 VGND VGND VPWR VPWR sky130_fd_sc_hd__decap_3
X_6997_ _7403_/CLK _6997_/D _6277_/Y VGND VGND VPWR VPWR _6997_/Q sky130_fd_sc_hd__dfrtp_2
XFILLER_43_15 VGND VGND VPWR VPWR sky130_fd_sc_hd__decap_3
XFILLER_53_598 VGND VGND VPWR VPWR sky130_fd_sc_hd__decap_3
XFILLER_80_395 VGND VGND VPWR VPWR sky130_fd_sc_hd__decap_3
XFILLER_40_259 VGND VGND VPWR VPWR sky130_fd_sc_hd__fill_2
XFILLER_5_606 VGND VGND VPWR VPWR sky130_fd_sc_hd__decap_3
XFILLER_5_617 VGND VGND VPWR VPWR sky130_fd_sc_hd__decap_3
XFILLER_107_523 VGND VGND VPWR VPWR sky130_fd_sc_hd__decap_3
XFILLER_4_127 VGND VGND VPWR VPWR sky130_fd_sc_hd__decap_3
XFILLER_108_41 VGND VGND VPWR VPWR sky130_fd_sc_hd__decap_3
XFILLER_108_74 VGND VGND VPWR VPWR sky130_fd_sc_hd__decap_3
XFILLER_108_85 VGND VGND VPWR VPWR sky130_fd_sc_hd__decap_3
XFILLER_68_23 VGND VGND VPWR VPWR sky130_fd_sc_hd__decap_3
XFILLER_0_333 VGND VGND VPWR VPWR sky130_fd_sc_hd__decap_3
XFILLER_88_451 VGND VGND VPWR VPWR sky130_fd_sc_hd__decap_3
XFILLER_0_388 VGND VGND VPWR VPWR sky130_fd_sc_hd__decap_3
XFILLER_48_315 VGND VGND VPWR VPWR sky130_fd_sc_hd__decap_3
XFILLER_75_101 VGND VGND VPWR VPWR sky130_fd_sc_hd__decap_3
XFILLER_88_462 VGND VGND VPWR VPWR sky130_fd_sc_hd__decap_3
XFILLER_0_399 VGND VGND VPWR VPWR sky130_fd_sc_hd__decap_3
XFILLER_102_283 VGND VGND VPWR VPWR sky130_fd_sc_hd__decap_3
XFILLER_48_348 VGND VGND VPWR VPWR sky130_fd_sc_hd__decap_3
XFILLER_76_657 VGND VGND VPWR VPWR sky130_fd_sc_hd__decap_3
XFILLER_63_318 VGND VGND VPWR VPWR sky130_fd_sc_hd__decap_3
XFILLER_75_178 VGND VGND VPWR VPWR sky130_fd_sc_hd__decap_3
XFILLER_84_44 VGND VGND VPWR VPWR sky130_fd_sc_hd__decap_3
XFILLER_91_605 VGND VGND VPWR VPWR sky130_fd_sc_hd__decap_3
XFILLER_16_212 VGND VGND VPWR VPWR sky130_fd_sc_hd__decap_3
XFILLER_56_392 VGND VGND VPWR VPWR sky130_fd_sc_hd__decap_3
XFILLER_84_690 VGND VGND VPWR VPWR sky130_fd_sc_hd__fill_2
XFILLER_84_99 VGND VGND VPWR VPWR sky130_fd_sc_hd__decap_3
XFILLER_91_638 VGND VGND VPWR VPWR sky130_fd_sc_hd__decap_3
Xplace318 _4422_/A2 VGND VGND VPWR VPWR _4437_/A2 sky130_fd_sc_hd__buf_2
Xplace307 _3548_/X VGND VGND VPWR VPWR _4948_/A sky130_fd_sc_hd__buf_2
XFILLER_16_256 VGND VGND VPWR VPWR sky130_fd_sc_hd__decap_3
XFILLER_17_60 VGND VGND VPWR VPWR sky130_fd_sc_hd__decap_3
XFILLER_71_340 VGND VGND VPWR VPWR sky130_fd_sc_hd__fill_1
XFILLER_90_159 VGND VGND VPWR VPWR sky130_fd_sc_hd__decap_3
Xplace329 _5708_/S VGND VGND VPWR VPWR _5721_/S sky130_fd_sc_hd__buf_2
XFILLER_17_93 VGND VGND VPWR VPWR sky130_fd_sc_hd__fill_1
XFILLER_44_587 VGND VGND VPWR VPWR sky130_fd_sc_hd__fill_1
XFILLER_71_362 VGND VGND VPWR VPWR sky130_fd_sc_hd__decap_3
XFILLER_71_384 VGND VGND VPWR VPWR sky130_fd_sc_hd__decap_3
XFILLER_31_237 VGND VGND VPWR VPWR sky130_fd_sc_hd__decap_3
XTAP_TAPCELL_ROW_42_755 VGND VPWR sky130_fd_sc_hd__tapvpwrvgnd_1
XTAP_TAPCELL_ROW_14_424 VGND VPWR sky130_fd_sc_hd__tapvpwrvgnd_1
XFILLER_83_9 VGND VGND VPWR VPWR sky130_fd_sc_hd__decap_3
XFILLER_33_81 VGND VGND VPWR VPWR sky130_fd_sc_hd__fill_1
XFILLER_8_477 VGND VGND VPWR VPWR sky130_fd_sc_hd__decap_3
XTAP_TAPCELL_ROW_113_1607 VGND VPWR sky130_fd_sc_hd__tapvpwrvgnd_1
XFILLER_4_672 VGND VGND VPWR VPWR sky130_fd_sc_hd__decap_3
XFILLER_98_237 VGND VGND VPWR VPWR sky130_fd_sc_hd__decap_3
XFILLER_113_559 VGND VGND VPWR VPWR sky130_fd_sc_hd__fill_1
XFILLER_98_259 VGND VGND VPWR VPWR sky130_fd_sc_hd__decap_3
XFILLER_67_635 VGND VGND VPWR VPWR sky130_fd_sc_hd__decap_3
XFILLER_79_484 VGND VGND VPWR VPWR sky130_fd_sc_hd__decap_3
XFILLER_12_3 VGND VGND VPWR VPWR sky130_fd_sc_hd__decap_3
XFILLER_39_337 VGND VGND VPWR VPWR sky130_fd_sc_hd__decap_3
XFILLER_66_123 VGND VGND VPWR VPWR sky130_fd_sc_hd__decap_3
XFILLER_67_668 VGND VGND VPWR VPWR sky130_fd_sc_hd__decap_3
XFILLER_94_421 VGND VGND VPWR VPWR sky130_fd_sc_hd__decap_3
XFILLER_66_156 VGND VGND VPWR VPWR sky130_fd_sc_hd__decap_3
XFILLER_67_679 VGND VGND VPWR VPWR sky130_fd_sc_hd__decap_3
XFILLER_82_616 VGND VGND VPWR VPWR sky130_fd_sc_hd__decap_3
XFILLER_94_465 VGND VGND VPWR VPWR sky130_fd_sc_hd__decap_3
XFILLER_35_532 VGND VGND VPWR VPWR sky130_fd_sc_hd__decap_3
XFILLER_94_498 VGND VGND VPWR VPWR sky130_fd_sc_hd__decap_3
X_6920_ clkload2/A _6920_/D VGND VGND VPWR VPWR _6920_/Q sky130_fd_sc_hd__dfxtp_2
XFILLER_90_660 VGND VGND VPWR VPWR sky130_fd_sc_hd__decap_3
X_6851_ _6946_/CLK _6851_/D VGND VGND VPWR VPWR _6851_/Q sky130_fd_sc_hd__dfxtp_2
XFILLER_62_384 VGND VGND VPWR VPWR sky130_fd_sc_hd__decap_3
Xfanout19 fanout39/X VGND VGND VPWR VPWR _6540_/A sky130_fd_sc_hd__buf_2
XFILLER_22_226 VGND VGND VPWR VPWR sky130_fd_sc_hd__decap_3
XFILLER_50_568 VGND VGND VPWR VPWR sky130_fd_sc_hd__fill_1
X_6782_ _7383_/CLK _6782_/D VGND VGND VPWR VPWR _6782_/Q sky130_fd_sc_hd__dfxtp_2
X_3994_ _3994_/A0 _3993_/X _3996_/S VGND VGND VPWR VPWR _7345_/D sky130_fd_sc_hd__mux2_2
XFILLER_13_29 VGND VGND VPWR VPWR sky130_fd_sc_hd__decap_3
X_5733_ _7372_/Q _5733_/A1 _5737_/S VGND VGND VPWR VPWR _6716_/D sky130_fd_sc_hd__mux2_2
X_5664_ _5664_/A _5664_/B _5664_/C _5664_/D VGND VGND VPWR VPWR _5665_/D sky130_fd_sc_hd__and4_2
XTAP_TAPCELL_ROW_79_1204 VGND VPWR sky130_fd_sc_hd__tapvpwrvgnd_1
X_7403_ _7403_/CLK _7403_/D _6683_/Y VGND VGND VPWR VPWR _7403_/Q sky130_fd_sc_hd__dfrtp_2
X_5595_ _5595_/A _5595_/B VGND VGND VPWR VPWR _7030_/D sky130_fd_sc_hd__or2_2
X_4615_ _4282_/Y _4612_/B _3610_/A VGND VGND VPWR VPWR _4615_/Y sky130_fd_sc_hd__a21oi_2
X_7334_ _7334_/CLK _7334_/D _6614_/Y VGND VGND VPWR VPWR _7334_/Q sky130_fd_sc_hd__dfrtp_2
X_4546_ _7307_/Q _4563_/B VGND VGND VPWR VPWR _7307_/D sky130_fd_sc_hd__and2_2
XFILLER_116_353 VGND VGND VPWR VPWR sky130_fd_sc_hd__decap_3
XFILLER_1_108 VGND VGND VPWR VPWR sky130_fd_sc_hd__decap_3
XFILLER_1_119 VGND VGND VPWR VPWR sky130_fd_sc_hd__decap_3
XFILLER_89_237 VGND VGND VPWR VPWR sky130_fd_sc_hd__decap_3
X_7265_ _7265_/CLK _7265_/D _6545_/Y VGND VGND VPWR VPWR _7265_/Q sky130_fd_sc_hd__dfrtp_2
X_7196_ _7390_/CLK _7196_/D _6476_/Y VGND VGND VPWR VPWR _7196_/Q sky130_fd_sc_hd__dfrtp_2
XFILLER_38_15 VGND VGND VPWR VPWR sky130_fd_sc_hd__decap_3
XFILLER_58_613 VGND VGND VPWR VPWR sky130_fd_sc_hd__decap_3
XFILLER_85_410 VGND VGND VPWR VPWR sky130_fd_sc_hd__decap_3
Xhold1100 _7300_/Q VGND VGND VPWR VPWR _4561_/A sky130_fd_sc_hd__dlygate4sd3_1
X_3359_ _6983_/Q _5130_/A VGND VGND VPWR VPWR _3376_/A sky130_fd_sc_hd__or2_2
XFILLER_112_581 VGND VGND VPWR VPWR sky130_fd_sc_hd__decap_3
XFILLER_112_592 VGND VGND VPWR VPWR sky130_fd_sc_hd__decap_3
XFILLER_57_134 VGND VGND VPWR VPWR sky130_fd_sc_hd__fill_2
XFILLER_58_657 VGND VGND VPWR VPWR sky130_fd_sc_hd__decap_3
XFILLER_97_281 VGND VGND VPWR VPWR sky130_fd_sc_hd__decap_3
Xhold1111 _7234_/Q VGND VGND VPWR VPWR _5188_/A sky130_fd_sc_hd__dlygate4sd3_1
Xhold1122 _7323_/Q VGND VGND VPWR VPWR _4513_/A0 sky130_fd_sc_hd__dlygate4sd3_1
Xhold1133 _7256_/Q VGND VGND VPWR VPWR _5095_/A0 sky130_fd_sc_hd__dlygate4sd3_1
XFILLER_57_167 VGND VGND VPWR VPWR sky130_fd_sc_hd__fill_1
Xhold1144 _7304_/Q VGND VGND VPWR VPWR _4552_/A sky130_fd_sc_hd__dlygate4sd3_1
Xhold1155 _7163_/Q VGND VGND VPWR VPWR _5336_/A0 sky130_fd_sc_hd__dlygate4sd3_1
Xhold1166 _7178_/Q VGND VGND VPWR VPWR _5304_/A0 sky130_fd_sc_hd__dlygate4sd3_1
XFILLER_66_690 VGND VGND VPWR VPWR sky130_fd_sc_hd__fill_2
XFILLER_73_638 VGND VGND VPWR VPWR sky130_fd_sc_hd__decap_3
Xhold1177 _7122_/Q VGND VGND VPWR VPWR _5423_/A0 sky130_fd_sc_hd__dlygate4sd3_1
Xhold1188 _7146_/Q VGND VGND VPWR VPWR _5373_/A0 sky130_fd_sc_hd__dlygate4sd3_1
Xhold1199 _7144_/Q VGND VGND VPWR VPWR _5377_/A0 sky130_fd_sc_hd__dlygate4sd3_1
XFILLER_54_36 VGND VGND VPWR VPWR sky130_fd_sc_hd__decap_3
XFILLER_72_148 VGND VGND VPWR VPWR sky130_fd_sc_hd__fill_2
XFILLER_53_384 VGND VGND VPWR VPWR sky130_fd_sc_hd__decap_3
XFILLER_81_671 VGND VGND VPWR VPWR sky130_fd_sc_hd__fill_1
XFILLER_81_682 VGND VGND VPWR VPWR sky130_fd_sc_hd__decap_3
XFILLER_110_53 VGND VGND VPWR VPWR sky130_fd_sc_hd__decap_3
XFILLER_80_181 VGND VGND VPWR VPWR sky130_fd_sc_hd__fill_1
XFILLER_70_24 VGND VGND VPWR VPWR sky130_fd_sc_hd__decap_3
XFILLER_110_97 VGND VGND VPWR VPWR sky130_fd_sc_hd__decap_3
XFILLER_21_281 VGND VGND VPWR VPWR sky130_fd_sc_hd__decap_3
XFILLER_70_46 VGND VGND VPWR VPWR sky130_fd_sc_hd__decap_3
XFILLER_107_320 VGND VGND VPWR VPWR sky130_fd_sc_hd__fill_1
XFILLER_5_414 VGND VGND VPWR VPWR sky130_fd_sc_hd__decap_3
XFILLER_5_447 VGND VGND VPWR VPWR sky130_fd_sc_hd__fill_1
XFILLER_79_11 VGND VGND VPWR VPWR sky130_fd_sc_hd__decap_3
XFILLER_5_458 VGND VGND VPWR VPWR sky130_fd_sc_hd__decap_3
XFILLER_79_44 VGND VGND VPWR VPWR sky130_fd_sc_hd__decap_3
XFILLER_79_55 VGND VGND VPWR VPWR sky130_fd_sc_hd__fill_1
XFILLER_79_66 VGND VGND VPWR VPWR sky130_fd_sc_hd__decap_3
XFILLER_1_631 VGND VGND VPWR VPWR sky130_fd_sc_hd__decap_3
XFILLER_79_99 VGND VGND VPWR VPWR sky130_fd_sc_hd__fill_2
XFILLER_0_141 VGND VGND VPWR VPWR sky130_fd_sc_hd__decap_3
XFILLER_1_664 VGND VGND VPWR VPWR sky130_fd_sc_hd__decap_3
XFILLER_48_123 VGND VGND VPWR VPWR sky130_fd_sc_hd__decap_3
XFILLER_49_635 VGND VGND VPWR VPWR sky130_fd_sc_hd__decap_3
XFILLER_76_421 VGND VGND VPWR VPWR sky130_fd_sc_hd__decap_3
XFILLER_95_43 VGND VGND VPWR VPWR sky130_fd_sc_hd__decap_3
XFILLER_36_307 VGND VGND VPWR VPWR sky130_fd_sc_hd__fill_1
XFILLER_49_668 VGND VGND VPWR VPWR sky130_fd_sc_hd__decap_3
XFILLER_49_679 VGND VGND VPWR VPWR sky130_fd_sc_hd__decap_3
XFILLER_64_616 VGND VGND VPWR VPWR sky130_fd_sc_hd__decap_3
XFILLER_76_454 VGND VGND VPWR VPWR sky130_fd_sc_hd__decap_3
XFILLER_95_98 VGND VGND VPWR VPWR sky130_fd_sc_hd__decap_3
XTAP_TAPCELL_ROW_47_814 VGND VPWR sky130_fd_sc_hd__tapvpwrvgnd_1
XFILLER_28_92 VGND VGND VPWR VPWR sky130_fd_sc_hd__decap_3
XFILLER_29_381 VGND VGND VPWR VPWR sky130_fd_sc_hd__decap_3
XFILLER_36_329 VGND VGND VPWR VPWR sky130_fd_sc_hd__decap_3
XFILLER_48_189 VGND VGND VPWR VPWR sky130_fd_sc_hd__decap_3
XFILLER_91_424 VGND VGND VPWR VPWR sky130_fd_sc_hd__decap_3
XFILLER_17_543 VGND VGND VPWR VPWR sky130_fd_sc_hd__decap_3
XFILLER_32_524 VGND VGND VPWR VPWR sky130_fd_sc_hd__decap_3
XFILLER_44_362 VGND VGND VPWR VPWR sky130_fd_sc_hd__fill_2
XFILLER_72_660 VGND VGND VPWR VPWR sky130_fd_sc_hd__decap_3
XTAP_TAPCELL_ROW_63_1005 VGND VPWR sky130_fd_sc_hd__tapvpwrvgnd_1
XTAP_TAPCELL_ROW_27_571 VGND VPWR sky130_fd_sc_hd__tapvpwrvgnd_1
XFILLER_44_80 VGND VGND VPWR VPWR sky130_fd_sc_hd__decap_3
XFILLER_71_181 VGND VGND VPWR VPWR sky130_fd_sc_hd__decap_3
XFILLER_81_6 VGND VGND VPWR VPWR sky130_fd_sc_hd__decap_3
XFILLER_12_292 VGND VGND VPWR VPWR sky130_fd_sc_hd__decap_3
XFILLER_60_90 VGND VGND VPWR VPWR sky130_fd_sc_hd__decap_3
XFILLER_8_296 VGND VGND VPWR VPWR sky130_fd_sc_hd__decap_3
X_4400_ _7178_/Q _4430_/B1 _5229_/C _7146_/Q _4399_/X VGND VGND VPWR VPWR _4400_/X
+ sky130_fd_sc_hd__a221o_2
XFILLER_5_30 VGND VGND VPWR VPWR sky130_fd_sc_hd__decap_3
Xoutput527 _6991_/Q VGND VGND VPWR VPWR pc_out[14] sky130_fd_sc_hd__clkdlybuf4s25_1
Xoutput516 _5640_/Y VGND VGND VPWR VPWR instruction_out[4] sky130_fd_sc_hd__clkdlybuf4s25_1
Xoutput505 _3417_/C VGND VGND VPWR VPWR instruction_out[21] sky130_fd_sc_hd__clkdlybuf4s25_1
XFILLER_5_63 VGND VGND VPWR VPWR sky130_fd_sc_hd__decap_3
Xoutput549 _5129_/A VGND VGND VPWR VPWR pc_out[5] sky130_fd_sc_hd__clkdlybuf4s25_1
Xoutput538 _7001_/Q VGND VGND VPWR VPWR pc_out[24] sky130_fd_sc_hd__clkdlybuf4s25_1
X_4331_ _7223_/Q _4331_/A2 _4517_/S _7036_/Q VGND VGND VPWR VPWR _4331_/X sky130_fd_sc_hd__a22o_2
XTAP_TAPCELL_ROW_74_1145 VGND VPWR sky130_fd_sc_hd__tapvpwrvgnd_1
XTAP_TAPCELL_ROW_74_1134 VGND VPWR sky130_fd_sc_hd__tapvpwrvgnd_1
XFILLER_99_524 VGND VGND VPWR VPWR sky130_fd_sc_hd__decap_3
XFILLER_5_96 VGND VGND VPWR VPWR sky130_fd_sc_hd__decap_3
X_7050_ _7403_/CLK _7050_/D _6330_/Y VGND VGND VPWR VPWR _7050_/Q sky130_fd_sc_hd__dfrtp_2
X_4262_ _7230_/Q _4262_/A2 _4503_/S _7294_/Q VGND VGND VPWR VPWR _4262_/X sky130_fd_sc_hd__a22o_2
XFILLER_99_557 VGND VGND VPWR VPWR sky130_fd_sc_hd__decap_3
XFILLER_113_389 VGND VGND VPWR VPWR sky130_fd_sc_hd__decap_3
XFILLER_79_292 VGND VGND VPWR VPWR sky130_fd_sc_hd__fill_1
X_4193_ _7359_/Q _4394_/B _4250_/A2 _7103_/Q VGND VGND VPWR VPWR _4193_/X sky130_fd_sc_hd__a22o_2
XFILLER_82_402 VGND VGND VPWR VPWR sky130_fd_sc_hd__decap_3
XFILLER_94_262 VGND VGND VPWR VPWR sky130_fd_sc_hd__fill_1
XFILLER_27_329 VGND VGND VPWR VPWR sky130_fd_sc_hd__fill_1
XFILLER_39_178 VGND VGND VPWR VPWR sky130_fd_sc_hd__decap_3
XFILLER_54_115 VGND VGND VPWR VPWR sky130_fd_sc_hd__decap_3
XFILLER_55_638 VGND VGND VPWR VPWR sky130_fd_sc_hd__decap_3
XFILLER_67_487 VGND VGND VPWR VPWR sky130_fd_sc_hd__decap_3
XFILLER_82_424 VGND VGND VPWR VPWR sky130_fd_sc_hd__decap_3
XFILLER_94_295 VGND VGND VPWR VPWR sky130_fd_sc_hd__decap_3
XFILLER_70_619 VGND VGND VPWR VPWR sky130_fd_sc_hd__decap_3
X_6903_ _6946_/CLK _6903_/D VGND VGND VPWR VPWR _6903_/Q sky130_fd_sc_hd__dfxtp_2
XFILLER_23_502 VGND VGND VPWR VPWR sky130_fd_sc_hd__fill_2
XFILLER_63_671 VGND VGND VPWR VPWR sky130_fd_sc_hd__fill_1
XFILLER_63_682 VGND VGND VPWR VPWR sky130_fd_sc_hd__fill_2
XTAP_TAPCELL_ROW_85_1274 VGND VPWR sky130_fd_sc_hd__tapvpwrvgnd_1
XFILLER_24_17 VGND VGND VPWR VPWR sky130_fd_sc_hd__decap_3
XFILLER_24_39 VGND VGND VPWR VPWR sky130_fd_sc_hd__decap_3
XFILLER_35_384 VGND VGND VPWR VPWR sky130_fd_sc_hd__fill_1
XFILLER_62_181 VGND VGND VPWR VPWR sky130_fd_sc_hd__fill_1
XFILLER_62_192 VGND VGND VPWR VPWR sky130_fd_sc_hd__decap_3
X_6834_ _6946_/CLK _6834_/D VGND VGND VPWR VPWR _6834_/Q sky130_fd_sc_hd__dfxtp_2
XFILLER_50_365 VGND VGND VPWR VPWR sky130_fd_sc_hd__decap_3
X_6765_ _6972_/CLK _6765_/D VGND VGND VPWR VPWR _6765_/Q sky130_fd_sc_hd__dfxtp_2
X_3977_ _7352_/Q hold978/X _3977_/S VGND VGND VPWR VPWR _7352_/D sky130_fd_sc_hd__mux2_2
XFILLER_10_218 VGND VGND VPWR VPWR sky130_fd_sc_hd__decap_3
XFILLER_108_106 VGND VGND VPWR VPWR sky130_fd_sc_hd__decap_3
XFILLER_109_629 VGND VGND VPWR VPWR sky130_fd_sc_hd__decap_3
XFILLER_40_27 VGND VGND VPWR VPWR sky130_fd_sc_hd__fill_1
X_6696_ _7384_/CLK _6696_/D VGND VGND VPWR VPWR _6696_/Q sky130_fd_sc_hd__dfxtp_2
XFILLER_108_139 VGND VGND VPWR VPWR sky130_fd_sc_hd__fill_1
XFILLER_40_49 VGND VGND VPWR VPWR sky130_fd_sc_hd__decap_3
X_5647_ _5647_/A _5647_/B VGND VGND VPWR VPWR _5647_/Y sky130_fd_sc_hd__nand2_2
XFILLER_104_312 VGND VGND VPWR VPWR sky130_fd_sc_hd__decap_3
XFILLER_116_161 VGND VGND VPWR VPWR sky130_fd_sc_hd__decap_3
XFILLER_116_172 VGND VGND VPWR VPWR sky130_fd_sc_hd__decap_3
XFILLER_2_439 VGND VGND VPWR VPWR sky130_fd_sc_hd__decap_3
X_7317_ clkload3/A _7317_/D _6597_/Y VGND VGND VPWR VPWR _7317_/Q sky130_fd_sc_hd__dfrtp_2
XFILLER_49_36 VGND VGND VPWR VPWR sky130_fd_sc_hd__decap_3
X_7248_ _7312_/CLK _7248_/D _6528_/Y VGND VGND VPWR VPWR _7248_/Q sky130_fd_sc_hd__dfrtp_2
XFILLER_104_389 VGND VGND VPWR VPWR sky130_fd_sc_hd__decap_3
XFILLER_105_42 VGND VGND VPWR VPWR sky130_fd_sc_hd__decap_3
X_7179_ _7310_/CLK _7179_/D _6459_/Y VGND VGND VPWR VPWR _7179_/Q sky130_fd_sc_hd__dfrtp_2
XFILLER_105_75 VGND VGND VPWR VPWR sky130_fd_sc_hd__decap_3
XFILLER_46_638 VGND VGND VPWR VPWR sky130_fd_sc_hd__decap_3
XFILLER_65_57 VGND VGND VPWR VPWR sky130_fd_sc_hd__decap_3
XFILLER_73_435 VGND VGND VPWR VPWR sky130_fd_sc_hd__decap_3
XFILLER_26_340 VGND VGND VPWR VPWR sky130_fd_sc_hd__fill_1
XFILLER_61_608 VGND VGND VPWR VPWR sky130_fd_sc_hd__decap_3
XFILLER_14_513 VGND VGND VPWR VPWR sky130_fd_sc_hd__decap_3
XFILLER_41_321 VGND VGND VPWR VPWR sky130_fd_sc_hd__decap_3
XFILLER_53_181 VGND VGND VPWR VPWR sky130_fd_sc_hd__fill_2
XFILLER_60_129 VGND VGND VPWR VPWR sky130_fd_sc_hd__decap_3
XFILLER_81_12 VGND VGND VPWR VPWR sky130_fd_sc_hd__decap_3
XFILLER_81_45 VGND VGND VPWR VPWR sky130_fd_sc_hd__decap_3
XFILLER_81_67 VGND VGND VPWR VPWR sky130_fd_sc_hd__fill_1
XTAP_TAPCELL_ROW_52_872 VGND VPWR sky130_fd_sc_hd__tapvpwrvgnd_1
XTAP_TAPCELL_ROW_24_541 VGND VPWR sky130_fd_sc_hd__tapvpwrvgnd_1
XFILLER_14_50 VGND VGND VPWR VPWR sky130_fd_sc_hd__decap_3
XFILLER_108_640 VGND VGND VPWR VPWR sky130_fd_sc_hd__decap_3
XFILLER_108_651 VGND VGND VPWR VPWR sky130_fd_sc_hd__decap_3
XFILLER_107_161 VGND VGND VPWR VPWR sky130_fd_sc_hd__decap_3
XFILLER_114_109 VGND VGND VPWR VPWR sky130_fd_sc_hd__decap_3
XFILLER_30_71 VGND VGND VPWR VPWR sky130_fd_sc_hd__decap_3
XFILLER_5_277 VGND VGND VPWR VPWR sky130_fd_sc_hd__decap_3
XFILLER_1_461 VGND VGND VPWR VPWR sky130_fd_sc_hd__decap_3
XFILLER_49_410 VGND VGND VPWR VPWR sky130_fd_sc_hd__decap_3
XFILLER_110_359 VGND VGND VPWR VPWR sky130_fd_sc_hd__decap_3
XFILLER_49_443 VGND VGND VPWR VPWR sky130_fd_sc_hd__fill_1
XFILLER_76_251 VGND VGND VPWR VPWR sky130_fd_sc_hd__fill_1
XFILLER_36_104 VGND VGND VPWR VPWR sky130_fd_sc_hd__fill_2
XFILLER_49_498 VGND VGND VPWR VPWR sky130_fd_sc_hd__decap_3
XFILLER_64_435 VGND VGND VPWR VPWR sky130_fd_sc_hd__fill_2
XFILLER_76_273 VGND VGND VPWR VPWR sky130_fd_sc_hd__decap_3
XFILLER_36_137 VGND VGND VPWR VPWR sky130_fd_sc_hd__decap_3
XFILLER_17_373 VGND VGND VPWR VPWR sky130_fd_sc_hd__fill_1
XFILLER_45_682 VGND VGND VPWR VPWR sky130_fd_sc_hd__decap_3
XFILLER_52_619 VGND VGND VPWR VPWR sky130_fd_sc_hd__decap_3
XFILLER_91_265 VGND VGND VPWR VPWR sky130_fd_sc_hd__decap_3
XFILLER_32_321 VGND VGND VPWR VPWR sky130_fd_sc_hd__fill_1
X_3900_ _3898_/X _3899_/X _5151_/A VGND VGND VPWR VPWR _3900_/Y sky130_fd_sc_hd__o21ai_2
XFILLER_20_505 VGND VGND VPWR VPWR sky130_fd_sc_hd__decap_3
XFILLER_32_343 VGND VGND VPWR VPWR sky130_fd_sc_hd__decap_3
XFILLER_60_663 VGND VGND VPWR VPWR sky130_fd_sc_hd__decap_3
X_3831_ _3682_/A _3828_/X _3830_/X _3714_/X VGND VGND VPWR VPWR _3831_/X sky130_fd_sc_hd__a22o_2
XFILLER_32_398 VGND VGND VPWR VPWR sky130_fd_sc_hd__decap_3
X_6550_ _6584_/A VGND VGND VPWR VPWR _6550_/Y sky130_fd_sc_hd__inv_2
X_3762_ _3746_/C _3759_/X _3760_/X _4832_/A VGND VGND VPWR VPWR _3762_/X sky130_fd_sc_hd__o31a_2
XFILLER_9_561 VGND VGND VPWR VPWR sky130_fd_sc_hd__fill_1
X_6481_ _6611_/A VGND VGND VPWR VPWR _6481_/Y sky130_fd_sc_hd__inv_2
X_3693_ _3693_/A0 _3692_/X _3757_/S VGND VGND VPWR VPWR _7403_/D sky130_fd_sc_hd__mux2_2
XFILLER_114_610 VGND VGND VPWR VPWR sky130_fd_sc_hd__decap_3
XFILLER_113_131 VGND VGND VPWR VPWR sky130_fd_sc_hd__decap_3
XFILLER_114_643 VGND VGND VPWR VPWR sky130_fd_sc_hd__fill_1
XFILLER_114_654 VGND VGND VPWR VPWR sky130_fd_sc_hd__decap_3
X_7102_ clkload7/A _7102_/D _6382_/Y VGND VGND VPWR VPWR _7102_/Q sky130_fd_sc_hd__dfrtp_2
X_4314_ _4376_/A _4364_/A _4364_/B _4313_/D VGND VGND VPWR VPWR _4315_/B sky130_fd_sc_hd__o31ai_2
XFILLER_113_164 VGND VGND VPWR VPWR sky130_fd_sc_hd__decap_3
XFILLER_114_687 VGND VGND VPWR VPWR sky130_fd_sc_hd__decap_3
XFILLER_59_218 VGND VGND VPWR VPWR sky130_fd_sc_hd__decap_3
XFILLER_87_505 VGND VGND VPWR VPWR sky130_fd_sc_hd__decap_3
XFILLER_87_516 VGND VGND VPWR VPWR sky130_fd_sc_hd__decap_3
X_5294_ _5294_/A _5294_/B VGND VGND VPWR VPWR _5294_/Y sky130_fd_sc_hd__nor2_2
XFILLER_99_387 VGND VGND VPWR VPWR sky130_fd_sc_hd__decap_3
XFILLER_101_337 VGND VGND VPWR VPWR sky130_fd_sc_hd__decap_3
XFILLER_113_175 VGND VGND VPWR VPWR sky130_fd_sc_hd__decap_3
XFILLER_19_17 VGND VGND VPWR VPWR sky130_fd_sc_hd__decap_3
X_7033_ _7384_/CLK _7033_/D _6313_/Y VGND VGND VPWR VPWR _7033_/Q sky130_fd_sc_hd__dfrtp_2
X_4245_ _7357_/Q _4261_/A2 _4261_/B1 _7165_/Q _4244_/X VGND VGND VPWR VPWR _4248_/B
+ sky130_fd_sc_hd__a221o_2
X_4176_ _7168_/Q _4261_/B1 _4348_/B1 _7136_/Q VGND VGND VPWR VPWR _4176_/X sky130_fd_sc_hd__a22o_2
XFILLER_28_627 VGND VGND VPWR VPWR sky130_fd_sc_hd__decap_3
XFILLER_95_593 VGND VGND VPWR VPWR sky130_fd_sc_hd__decap_3
XFILLER_27_137 VGND VGND VPWR VPWR sky130_fd_sc_hd__decap_3
XFILLER_82_232 VGND VGND VPWR VPWR sky130_fd_sc_hd__decap_3
XFILLER_42_118 VGND VGND VPWR VPWR sky130_fd_sc_hd__fill_1
XFILLER_70_427 VGND VGND VPWR VPWR sky130_fd_sc_hd__decap_3
XFILLER_82_265 VGND VGND VPWR VPWR sky130_fd_sc_hd__decap_3
XFILLER_23_321 VGND VGND VPWR VPWR sky130_fd_sc_hd__decap_3
XFILLER_35_181 VGND VGND VPWR VPWR sky130_fd_sc_hd__decap_3
XFILLER_51_641 VGND VGND VPWR VPWR sky130_fd_sc_hd__decap_3
X_6817_ _6970_/CLK _6817_/D VGND VGND VPWR VPWR _6817_/Q sky130_fd_sc_hd__dfxtp_2
XFILLER_11_549 VGND VGND VPWR VPWR sky130_fd_sc_hd__fill_2
XFILLER_23_387 VGND VGND VPWR VPWR sky130_fd_sc_hd__fill_2
XFILLER_51_15 VGND VGND VPWR VPWR sky130_fd_sc_hd__decap_3
XFILLER_51_685 VGND VGND VPWR VPWR sky130_fd_sc_hd__decap_3
XTAP_TAPCELL_ROW_21_500 VGND VPWR sky130_fd_sc_hd__tapvpwrvgnd_1
X_6748_ _6970_/CLK _6748_/D VGND VGND VPWR VPWR _6748_/Q sky130_fd_sc_hd__dfxtp_2
X_6679_ _6682_/A VGND VGND VPWR VPWR _6679_/Y sky130_fd_sc_hd__inv_2
XTAP_TAPCELL_ROW_98_1432 VGND VPWR sky130_fd_sc_hd__tapvpwrvgnd_1
XFILLER_105_610 VGND VGND VPWR VPWR sky130_fd_sc_hd__decap_3
XFILLER_2_203 VGND VGND VPWR VPWR sky130_fd_sc_hd__decap_3
XFILLER_104_131 VGND VGND VPWR VPWR sky130_fd_sc_hd__decap_3
XFILLER_105_632 VGND VGND VPWR VPWR sky130_fd_sc_hd__decap_3
XFILLER_104_153 VGND VGND VPWR VPWR sky130_fd_sc_hd__fill_2
XFILLER_105_665 VGND VGND VPWR VPWR sky130_fd_sc_hd__decap_3
XFILLER_105_676 VGND VGND VPWR VPWR sky130_fd_sc_hd__decap_3
XFILLER_116_41 VGND VGND VPWR VPWR sky130_fd_sc_hd__decap_3
XFILLER_78_527 VGND VGND VPWR VPWR sky130_fd_sc_hd__fill_2
XFILLER_104_197 VGND VGND VPWR VPWR sky130_fd_sc_hd__decap_3
XFILLER_116_74 VGND VGND VPWR VPWR sky130_fd_sc_hd__decap_3
XFILLER_116_85 VGND VGND VPWR VPWR sky130_fd_sc_hd__fill_1
XFILLER_76_12 VGND VGND VPWR VPWR sky130_fd_sc_hd__decap_3
XFILLER_58_251 VGND VGND VPWR VPWR sky130_fd_sc_hd__fill_1
XFILLER_76_56 VGND VGND VPWR VPWR sky130_fd_sc_hd__decap_3
XFILLER_93_508 VGND VGND VPWR VPWR sky130_fd_sc_hd__decap_3
XFILLER_18_104 VGND VGND VPWR VPWR sky130_fd_sc_hd__decap_3
XFILLER_46_424 VGND VGND VPWR VPWR sky130_fd_sc_hd__decap_3
XFILLER_73_210 VGND VGND VPWR VPWR sky130_fd_sc_hd__decap_3
XTAP_TAPCELL_ROW_29_600 VGND VPWR sky130_fd_sc_hd__tapvpwrvgnd_1
XFILLER_100_392 VGND VGND VPWR VPWR sky130_fd_sc_hd__decap_3
XFILLER_34_608 VGND VGND VPWR VPWR sky130_fd_sc_hd__decap_3
XFILLER_46_446 VGND VGND VPWR VPWR sky130_fd_sc_hd__fill_1
XTAP_TAPCELL_ROW_57_931 VGND VPWR sky130_fd_sc_hd__tapvpwrvgnd_1
XFILLER_27_671 VGND VGND VPWR VPWR sky130_fd_sc_hd__fill_1
XFILLER_61_405 VGND VGND VPWR VPWR sky130_fd_sc_hd__fill_1
XFILLER_73_254 VGND VGND VPWR VPWR sky130_fd_sc_hd__decap_3
XFILLER_73_287 VGND VGND VPWR VPWR sky130_fd_sc_hd__fill_1
XFILLER_92_44 VGND VGND VPWR VPWR sky130_fd_sc_hd__decap_3
XFILLER_92_66 VGND VGND VPWR VPWR sky130_fd_sc_hd__fill_1
XFILLER_14_365 VGND VGND VPWR VPWR sky130_fd_sc_hd__decap_3
XFILLER_25_60 VGND VGND VPWR VPWR sky130_fd_sc_hd__decap_3
XFILLER_42_674 VGND VGND VPWR VPWR sky130_fd_sc_hd__decap_3
XFILLER_41_81 VGND VGND VPWR VPWR sky130_fd_sc_hd__decap_3
XFILLER_44_6 VGND VGND VPWR VPWR sky130_fd_sc_hd__decap_3
XFILLER_69_505 VGND VGND VPWR VPWR sky130_fd_sc_hd__fill_1
XTAP_TAPCELL_ROW_71_1104 VGND VPWR sky130_fd_sc_hd__tapvpwrvgnd_1
XFILLER_110_112 VGND VGND VPWR VPWR sky130_fd_sc_hd__decap_3
XFILLER_111_635 VGND VGND VPWR VPWR sky130_fd_sc_hd__decap_3
XFILLER_110_156 VGND VGND VPWR VPWR sky130_fd_sc_hd__decap_3
XFILLER_111_668 VGND VGND VPWR VPWR sky130_fd_sc_hd__decap_3
XFILLER_111_679 VGND VGND VPWR VPWR sky130_fd_sc_hd__decap_3
XFILLER_2_20 VGND VGND VPWR VPWR sky130_fd_sc_hd__decap_3
XFILLER_2_53 VGND VGND VPWR VPWR sky130_fd_sc_hd__decap_3
XFILLER_49_251 VGND VGND VPWR VPWR sky130_fd_sc_hd__fill_1
XFILLER_84_519 VGND VGND VPWR VPWR sky130_fd_sc_hd__fill_1
XFILLER_96_379 VGND VGND VPWR VPWR sky130_fd_sc_hd__decap_3
XPHY_EDGE_ROW_10_Right_10 VGND VGND VPWR VPWR sky130_fd_sc_hd__decap_3
XFILLER_110_189 VGND VGND VPWR VPWR sky130_fd_sc_hd__decap_3
XFILLER_49_273 VGND VGND VPWR VPWR sky130_fd_sc_hd__fill_1
XFILLER_2_97 VGND VGND VPWR VPWR sky130_fd_sc_hd__decap_3
XFILLER_37_446 VGND VGND VPWR VPWR sky130_fd_sc_hd__fill_2
XFILLER_49_295 VGND VGND VPWR VPWR sky130_fd_sc_hd__decap_3
XFILLER_52_405 VGND VGND VPWR VPWR sky130_fd_sc_hd__decap_3
XFILLER_64_265 VGND VGND VPWR VPWR sky130_fd_sc_hd__fill_2
XFILLER_64_276 VGND VGND VPWR VPWR sky130_fd_sc_hd__decap_3
XFILLER_92_563 VGND VGND VPWR VPWR sky130_fd_sc_hd__decap_3
XTAP_TAPCELL_ROW_69_1077 VGND VPWR sky130_fd_sc_hd__tapvpwrvgnd_1
XFILLER_24_118 VGND VGND VPWR VPWR sky130_fd_sc_hd__decap_3
XFILLER_52_427 VGND VGND VPWR VPWR sky130_fd_sc_hd__decap_3
Xclkbuf_leaf_44_clk clkbuf_3_0__f_clk/X VGND VGND VPWR VPWR clkload5/A sky130_fd_sc_hd__clkbuf_16
X_4932_ _5092_/C _4927_/X _4929_/Y _6996_/D _4997_/A1 VGND VGND VPWR VPWR _4932_/X
+ sky130_fd_sc_hd__a32o_2
XTAP_TAPCELL_ROW_82_1233 VGND VPWR sky130_fd_sc_hd__tapvpwrvgnd_1
XTAP_TAPCELL_ROW_35_669 VGND VPWR sky130_fd_sc_hd__tapvpwrvgnd_1
XFILLER_60_460 VGND VGND VPWR VPWR sky130_fd_sc_hd__decap_3
X_6602_ _6664_/A VGND VGND VPWR VPWR _6602_/Y sky130_fd_sc_hd__inv_2
XFILLER_20_335 VGND VGND VPWR VPWR sky130_fd_sc_hd__decap_3
X_3814_ _3814_/A1 _4466_/A _3813_/Y VGND VGND VPWR VPWR _7391_/D sky130_fd_sc_hd__a21bo_2
XFILLER_21_18 VGND VGND VPWR VPWR sky130_fd_sc_hd__decap_3
X_6533_ _6568_/A VGND VGND VPWR VPWR _6533_/Y sky130_fd_sc_hd__inv_2
X_3745_ _6978_/Q _3651_/Y _3892_/B1 _6723_/Q _3744_/X VGND VGND VPWR VPWR _3745_/X
+ sky130_fd_sc_hd__a221o_2
X_6464_ _6672_/A VGND VGND VPWR VPWR _6464_/Y sky130_fd_sc_hd__inv_2
XFILLER_9_391 VGND VGND VPWR VPWR sky130_fd_sc_hd__fill_1
XFILLER_106_407 VGND VGND VPWR VPWR sky130_fd_sc_hd__decap_3
X_5415_ _7126_/Q _5121_/X _5423_/S VGND VGND VPWR VPWR _7126_/D sky130_fd_sc_hd__mux2_2
X_3676_ _6716_/Q VGND VGND VPWR VPWR _3676_/Y sky130_fd_sc_hd__inv_2
X_6395_ _6523_/A VGND VGND VPWR VPWR _6395_/Y sky130_fd_sc_hd__inv_2
XFILLER_114_473 VGND VGND VPWR VPWR sky130_fd_sc_hd__decap_3
X_5346_ _5346_/A0 _5121_/X _5358_/S VGND VGND VPWR VPWR _7158_/D sky130_fd_sc_hd__mux2_2
XTAP_TAPCELL_ROW_93_1373 VGND VPWR sky130_fd_sc_hd__tapvpwrvgnd_1
XTAP_TAPCELL_ROW_93_1362 VGND VPWR sky130_fd_sc_hd__tapvpwrvgnd_1
XTAP_TAPCELL_ROW_7_339 VGND VPWR sky130_fd_sc_hd__tapvpwrvgnd_1
XFILLER_101_101 VGND VGND VPWR VPWR sky130_fd_sc_hd__fill_1
XFILLER_101_123 VGND VGND VPWR VPWR sky130_fd_sc_hd__decap_3
XFILLER_102_624 VGND VGND VPWR VPWR sky130_fd_sc_hd__decap_3
XFILLER_101_145 VGND VGND VPWR VPWR sky130_fd_sc_hd__decap_3
XFILLER_102_657 VGND VGND VPWR VPWR sky130_fd_sc_hd__decap_3
XFILLER_75_508 VGND VGND VPWR VPWR sky130_fd_sc_hd__decap_3
X_7016_ _7294_/CLK _7016_/D _6296_/Y VGND VGND VPWR VPWR _7016_/Q sky130_fd_sc_hd__dfrtp_2
X_4228_ _7014_/Q _4341_/A2 _3977_/S _7195_/Q _4227_/X VGND VGND VPWR VPWR _4228_/X
+ sky130_fd_sc_hd__a221o_2
XFILLER_101_178 VGND VGND VPWR VPWR sky130_fd_sc_hd__fill_1
XFILLER_101_189 VGND VGND VPWR VPWR sky130_fd_sc_hd__decap_3
XFILLER_28_424 VGND VGND VPWR VPWR sky130_fd_sc_hd__decap_3
XFILLER_68_571 VGND VGND VPWR VPWR sky130_fd_sc_hd__decap_3
XFILLER_110_690 VGND VGND VPWR VPWR sky130_fd_sc_hd__fill_2
XFILLER_46_26 VGND VGND VPWR VPWR sky130_fd_sc_hd__fill_2
XFILLER_55_221 VGND VGND VPWR VPWR sky130_fd_sc_hd__decap_3
X_4159_ _7329_/Q _4268_/A2 _4429_/B1 _7361_/Q _4248_/A VGND VGND VPWR VPWR _4159_/X
+ sky130_fd_sc_hd__a221o_2
XPHY_EDGE_ROW_106_Right_106 VGND VGND VPWR VPWR sky130_fd_sc_hd__decap_3
XFILLER_102_21 VGND VGND VPWR VPWR sky130_fd_sc_hd__decap_3
XFILLER_55_254 VGND VGND VPWR VPWR sky130_fd_sc_hd__decap_3
XTAP_TAPCELL_ROW_54_901 VGND VPWR sky130_fd_sc_hd__tapvpwrvgnd_1
XFILLER_102_32 VGND VGND VPWR VPWR sky130_fd_sc_hd__decap_3
XFILLER_102_43 VGND VGND VPWR VPWR sky130_fd_sc_hd__decap_3
XFILLER_55_287 VGND VGND VPWR VPWR sky130_fd_sc_hd__decap_3
Xclkbuf_leaf_35_clk clkbuf_3_0__f_clk/X VGND VGND VPWR VPWR _7384_/CLK sky130_fd_sc_hd__clkbuf_16
XFILLER_23_162 VGND VGND VPWR VPWR sky130_fd_sc_hd__decap_3
XFILLER_23_184 VGND VGND VPWR VPWR sky130_fd_sc_hd__decap_3
XTAP_TAPCELL_ROW_102_1480 VGND VPWR sky130_fd_sc_hd__tapvpwrvgnd_1
XFILLER_109_278 VGND VGND VPWR VPWR sky130_fd_sc_hd__fill_2
XFILLER_11_51 VGND VGND VPWR VPWR sky130_fd_sc_hd__decap_3
XFILLER_3_501 VGND VGND VPWR VPWR sky130_fd_sc_hd__decap_3
XFILLER_11_84 VGND VGND VPWR VPWR sky130_fd_sc_hd__decap_3
XFILLER_105_440 VGND VGND VPWR VPWR sky130_fd_sc_hd__decap_3
XFILLER_3_578 VGND VGND VPWR VPWR sky130_fd_sc_hd__decap_3
XFILLER_87_66 VGND VGND VPWR VPWR sky130_fd_sc_hd__decap_3
XFILLER_66_519 VGND VGND VPWR VPWR sky130_fd_sc_hd__decap_3
XFILLER_78_368 VGND VGND VPWR VPWR sky130_fd_sc_hd__decap_3
XFILLER_87_88 VGND VGND VPWR VPWR sky130_fd_sc_hd__fill_2
XFILLER_46_221 VGND VGND VPWR VPWR sky130_fd_sc_hd__decap_3
XFILLER_59_593 VGND VGND VPWR VPWR sky130_fd_sc_hd__decap_3
XFILLER_74_530 VGND VGND VPWR VPWR sky130_fd_sc_hd__fill_2
XFILLER_46_265 VGND VGND VPWR VPWR sky130_fd_sc_hd__decap_3
XFILLER_61_202 VGND VGND VPWR VPWR sky130_fd_sc_hd__decap_3
XTAP_TAPCELL_ROW_105_1509 VGND VPWR sky130_fd_sc_hd__tapvpwrvgnd_1
XFILLER_46_287 VGND VGND VPWR VPWR sky130_fd_sc_hd__decap_3
XFILLER_36_92 VGND VGND VPWR VPWR sky130_fd_sc_hd__decap_3
Xclkbuf_leaf_26_clk clkload0/A VGND VGND VPWR VPWR _6971_/CLK sky130_fd_sc_hd__clkbuf_16
XTAP_TAPCELL_ROW_32_639 VGND VPWR sky130_fd_sc_hd__tapvpwrvgnd_1
XFILLER_42_493 VGND VGND VPWR VPWR sky130_fd_sc_hd__decap_3
XFILLER_52_80 VGND VGND VPWR VPWR sky130_fd_sc_hd__decap_3
XTAP_TAPCELL_ROW_12_396 VGND VPWR sky130_fd_sc_hd__tapvpwrvgnd_1
Xhold807 _6923_/Q VGND VGND VPWR VPWR _6923_/D sky130_fd_sc_hd__dlygate4sd3_1
Xhold818 _6879_/Q VGND VGND VPWR VPWR _6879_/D sky130_fd_sc_hd__dlygate4sd3_1
XTAP_TAPCELL_ROW_116_1649 VGND VPWR sky130_fd_sc_hd__tapvpwrvgnd_1
XTAP_TAPCELL_ROW_116_1638 VGND VPWR sky130_fd_sc_hd__tapvpwrvgnd_1
XFILLER_115_237 VGND VGND VPWR VPWR sky130_fd_sc_hd__decap_3
Xhold829 _6959_/Q VGND VGND VPWR VPWR _6959_/D sky130_fd_sc_hd__dlygate4sd3_1
Xmax_cap559 _5047_/Y VGND VGND VPWR VPWR _5084_/B sky130_fd_sc_hd__buf_1
X_3461_ _7281_/Q _4503_/S _4339_/B1 _7153_/Q _3460_/X VGND VGND VPWR VPWR _3461_/X
+ sky130_fd_sc_hd__a221o_2
XFILLER_42_3 VGND VGND VPWR VPWR sky130_fd_sc_hd__decap_3
XFILLER_69_302 VGND VGND VPWR VPWR sky130_fd_sc_hd__decap_3
X_5200_ _5200_/A _5225_/B VGND VGND VPWR VPWR _7228_/D sky130_fd_sc_hd__and2_2
X_3392_ _3392_/A _3429_/B VGND VGND VPWR VPWR _3591_/A sky130_fd_sc_hd__nor2_2
XFILLER_69_335 VGND VGND VPWR VPWR sky130_fd_sc_hd__fill_1
XFILLER_96_121 VGND VGND VPWR VPWR sky130_fd_sc_hd__decap_3
X_5131_ _3992_/Y _5128_/Y wire571/X _5156_/S VGND VGND VPWR VPWR _5131_/X sky130_fd_sc_hd__o22a_2
XFILLER_97_644 VGND VGND VPWR VPWR sky130_fd_sc_hd__decap_3
XFILLER_57_508 VGND VGND VPWR VPWR sky130_fd_sc_hd__fill_1
XFILLER_57_519 VGND VGND VPWR VPWR sky130_fd_sc_hd__decap_3
XFILLER_97_688 VGND VGND VPWR VPWR sky130_fd_sc_hd__decap_3
XFILLER_37_210 VGND VGND VPWR VPWR sky130_fd_sc_hd__fill_1
XFILLER_25_405 VGND VGND VPWR VPWR sky130_fd_sc_hd__decap_3
XFILLER_92_360 VGND VGND VPWR VPWR sky130_fd_sc_hd__decap_3
XFILLER_16_18 VGND VGND VPWR VPWR sky130_fd_sc_hd__decap_3
XFILLER_16_29 VGND VGND VPWR VPWR sky130_fd_sc_hd__decap_3
XFILLER_25_438 VGND VGND VPWR VPWR sky130_fd_sc_hd__fill_1
XFILLER_25_449 VGND VGND VPWR VPWR sky130_fd_sc_hd__fill_1
XFILLER_37_298 VGND VGND VPWR VPWR sky130_fd_sc_hd__fill_2
XFILLER_65_585 VGND VGND VPWR VPWR sky130_fd_sc_hd__decap_3
Xclkbuf_leaf_17_clk clkload1/A VGND VGND VPWR VPWR _7374_/CLK sky130_fd_sc_hd__clkbuf_16
XFILLER_33_471 VGND VGND VPWR VPWR sky130_fd_sc_hd__decap_3
X_4846_ _4903_/A _4890_/B VGND VGND VPWR VPWR _4884_/A sky130_fd_sc_hd__nand2_2
XFILLER_20_187 VGND VGND VPWR VPWR sky130_fd_sc_hd__decap_3
X_6516_ _6610_/A VGND VGND VPWR VPWR _6516_/Y sky130_fd_sc_hd__inv_2
X_4777_ _4983_/A _4777_/B _4777_/C VGND VGND VPWR VPWR _4777_/X sky130_fd_sc_hd__and3_2
XFILLER_113_9 VGND VGND VPWR VPWR sky130_fd_sc_hd__decap_3
X_3728_ _3746_/A _3728_/B VGND VGND VPWR VPWR _3728_/Y sky130_fd_sc_hd__nor2_2
XFILLER_106_248 VGND VGND VPWR VPWR sky130_fd_sc_hd__decap_3
X_6447_ _6610_/A VGND VGND VPWR VPWR _6447_/Y sky130_fd_sc_hd__inv_2
XFILLER_106_259 VGND VGND VPWR VPWR sky130_fd_sc_hd__decap_3
X_6378_ _6539_/A VGND VGND VPWR VPWR _6378_/Y sky130_fd_sc_hd__inv_2
XFILLER_102_421 VGND VGND VPWR VPWR sky130_fd_sc_hd__decap_3
XFILLER_87_110 VGND VGND VPWR VPWR sky130_fd_sc_hd__fill_2
XFILLER_88_611 VGND VGND VPWR VPWR sky130_fd_sc_hd__decap_3
X_5329_ _5329_/A0 _4997_/X _5360_/S VGND VGND VPWR VPWR _7166_/D sky130_fd_sc_hd__mux2_2
XFILLER_102_454 VGND VGND VPWR VPWR sky130_fd_sc_hd__decap_3
XFILLER_114_292 VGND VGND VPWR VPWR sky130_fd_sc_hd__decap_3
XFILLER_57_14 VGND VGND VPWR VPWR sky130_fd_sc_hd__decap_3
XFILLER_87_143 VGND VGND VPWR VPWR sky130_fd_sc_hd__decap_3
XFILLER_88_666 VGND VGND VPWR VPWR sky130_fd_sc_hd__decap_3
XFILLER_48_519 VGND VGND VPWR VPWR sky130_fd_sc_hd__decap_3
XFILLER_56_541 VGND VGND VPWR VPWR sky130_fd_sc_hd__fill_2
XFILLER_68_390 VGND VGND VPWR VPWR sky130_fd_sc_hd__decap_3
XFILLER_75_349 VGND VGND VPWR VPWR sky130_fd_sc_hd__decap_3
XFILLER_113_42 VGND VGND VPWR VPWR sky130_fd_sc_hd__decap_3
XFILLER_28_243 VGND VGND VPWR VPWR sky130_fd_sc_hd__decap_3
XFILLER_28_265 VGND VGND VPWR VPWR sky130_fd_sc_hd__decap_3
XFILLER_113_75 VGND VGND VPWR VPWR sky130_fd_sc_hd__decap_3
XFILLER_28_298 VGND VGND VPWR VPWR sky130_fd_sc_hd__fill_1
XFILLER_71_522 VGND VGND VPWR VPWR sky130_fd_sc_hd__fill_2
XFILLER_73_46 VGND VGND VPWR VPWR sky130_fd_sc_hd__decap_3
XFILLER_83_393 VGND VGND VPWR VPWR sky130_fd_sc_hd__decap_3
XFILLER_43_246 VGND VGND VPWR VPWR sky130_fd_sc_hd__decap_3
XFILLER_73_57 VGND VGND VPWR VPWR sky130_fd_sc_hd__decap_3
XFILLER_24_493 VGND VGND VPWR VPWR sky130_fd_sc_hd__fill_2
XFILLER_51_290 VGND VGND VPWR VPWR sky130_fd_sc_hd__fill_1
XFILLER_12_677 VGND VGND VPWR VPWR sky130_fd_sc_hd__decap_3
XFILLER_22_61 VGND VGND VPWR VPWR sky130_fd_sc_hd__decap_3
XFILLER_7_125 VGND VGND VPWR VPWR sky130_fd_sc_hd__decap_3
XFILLER_8_659 VGND VGND VPWR VPWR sky130_fd_sc_hd__decap_3
XFILLER_22_83 VGND VGND VPWR VPWR sky130_fd_sc_hd__fill_1
XFILLER_7_158 VGND VGND VPWR VPWR sky130_fd_sc_hd__decap_3
XFILLER_98_65 VGND VGND VPWR VPWR sky130_fd_sc_hd__decap_3
XFILLER_112_218 VGND VGND VPWR VPWR sky130_fd_sc_hd__decap_3
XFILLER_3_375 VGND VGND VPWR VPWR sky130_fd_sc_hd__decap_3
XFILLER_78_110 VGND VGND VPWR VPWR sky130_fd_sc_hd__decap_3
XFILLER_79_611 VGND VGND VPWR VPWR sky130_fd_sc_hd__decap_3
XFILLER_105_281 VGND VGND VPWR VPWR sky130_fd_sc_hd__decap_3
XFILLER_79_644 VGND VGND VPWR VPWR sky130_fd_sc_hd__decap_3
XTAP_TAPCELL_ROW_111_1579 VGND VPWR sky130_fd_sc_hd__tapvpwrvgnd_1
XFILLER_78_165 VGND VGND VPWR VPWR sky130_fd_sc_hd__decap_3
XFILLER_79_688 VGND VGND VPWR VPWR sky130_fd_sc_hd__decap_3
XFILLER_93_113 VGND VGND VPWR VPWR sky130_fd_sc_hd__decap_3
XFILLER_94_636 VGND VGND VPWR VPWR sky130_fd_sc_hd__decap_3
XFILLER_19_221 VGND VGND VPWR VPWR sky130_fd_sc_hd__decap_3
XFILLER_66_338 VGND VGND VPWR VPWR sky130_fd_sc_hd__decap_3
XFILLER_66_349 VGND VGND VPWR VPWR sky130_fd_sc_hd__fill_1
XFILLER_94_669 VGND VGND VPWR VPWR sky130_fd_sc_hd__decap_3
XFILLER_19_254 VGND VGND VPWR VPWR sky130_fd_sc_hd__decap_3
XFILLER_47_80 VGND VGND VPWR VPWR sky130_fd_sc_hd__decap_3
XFILLER_62_500 VGND VGND VPWR VPWR sky130_fd_sc_hd__fill_1
XFILLER_93_157 VGND VGND VPWR VPWR sky130_fd_sc_hd__decap_3
XFILLER_34_224 VGND VGND VPWR VPWR sky130_fd_sc_hd__fill_1
XFILLER_74_371 VGND VGND VPWR VPWR sky130_fd_sc_hd__fill_2
XFILLER_22_408 VGND VGND VPWR VPWR sky130_fd_sc_hd__decap_3
XFILLER_34_246 VGND VGND VPWR VPWR sky130_fd_sc_hd__decap_3
XTAP_TAPCELL_ROW_66_1047 VGND VPWR sky130_fd_sc_hd__tapvpwrvgnd_1
XTAP_TAPCELL_ROW_17_455 VGND VPWR sky130_fd_sc_hd__tapvpwrvgnd_1
XTAP_TAPCELL_ROW_45_797 VGND VPWR sky130_fd_sc_hd__tapvpwrvgnd_1
XTAP_TAPCELL_ROW_45_786 VGND VPWR sky130_fd_sc_hd__tapvpwrvgnd_1
X_5680_ _7346_/Q hold958/X _5706_/S VGND VGND VPWR VPWR _6690_/D sky130_fd_sc_hd__mux2_2
X_4700_ _6988_/Q _5066_/A VGND VGND VPWR VPWR _5044_/A sky130_fd_sc_hd__and2_2
XFILLER_8_41 VGND VGND VPWR VPWR sky130_fd_sc_hd__decap_3
X_4631_ _5003_/A _4620_/C _4630_/X _4273_/Y VGND VGND VPWR VPWR _4631_/X sky130_fd_sc_hd__a31o_2
XFILLER_30_485 VGND VGND VPWR VPWR sky130_fd_sc_hd__decap_3
XFILLER_8_74 VGND VGND VPWR VPWR sky130_fd_sc_hd__decap_3
XFILLER_8_85 VGND VGND VPWR VPWR sky130_fd_sc_hd__decap_3
XFILLER_116_513 VGND VGND VPWR VPWR sky130_fd_sc_hd__decap_3
X_7350_ _7384_/CLK _7350_/D _6630_/Y VGND VGND VPWR VPWR _7350_/Q sky130_fd_sc_hd__dfrtp_2
X_7281_ _7352_/CLK _7281_/D _6561_/Y VGND VGND VPWR VPWR _7281_/Q sky130_fd_sc_hd__dfrtp_2
Xhold604 _6779_/Q VGND VGND VPWR VPWR _6779_/D sky130_fd_sc_hd__dlygate4sd3_1
Xhold615 _6890_/Q VGND VGND VPWR VPWR _6890_/D sky130_fd_sc_hd__dlygate4sd3_1
Xhold626 _6892_/Q VGND VGND VPWR VPWR _6892_/D sky130_fd_sc_hd__dlygate4sd3_1
X_6301_ _6644_/A VGND VGND VPWR VPWR _6301_/Y sky130_fd_sc_hd__inv_2
X_4493_ _4493_/A0 _7301_/Q _4493_/S VGND VGND VPWR VPWR _7333_/D sky130_fd_sc_hd__mux2_2
XFILLER_116_557 VGND VGND VPWR VPWR sky130_fd_sc_hd__decap_3
XFILLER_89_408 VGND VGND VPWR VPWR sky130_fd_sc_hd__fill_1
Xclkbuf_leaf_6_clk clkbuf_leaf_9_clk/A VGND VGND VPWR VPWR _7363_/CLK sky130_fd_sc_hd__clkbuf_16
Xhold637 _6797_/Q VGND VGND VPWR VPWR _6797_/D sky130_fd_sc_hd__dlygate4sd3_1
Xhold648 _6926_/Q VGND VGND VPWR VPWR _6926_/D sky130_fd_sc_hd__dlygate4sd3_1
Xhold659 _6814_/Q VGND VGND VPWR VPWR _6814_/D sky130_fd_sc_hd__dlygate4sd3_1
XTAP_TAPCELL_ROW_77_1176 VGND VPWR sky130_fd_sc_hd__tapvpwrvgnd_1
XTAP_TAPCELL_ROW_90_1332 VGND VPWR sky130_fd_sc_hd__tapvpwrvgnd_1
X_3375_ _5118_/A _3399_/B VGND VGND VPWR VPWR _5641_/A sky130_fd_sc_hd__nand2_2
XFILLER_57_316 VGND VGND VPWR VPWR sky130_fd_sc_hd__decap_3
XFILLER_84_102 VGND VGND VPWR VPWR sky130_fd_sc_hd__decap_3
XFILLER_85_614 VGND VGND VPWR VPWR sky130_fd_sc_hd__fill_2
XFILLER_97_485 VGND VGND VPWR VPWR sky130_fd_sc_hd__fill_1
X_5114_ _5114_/A _5114_/B VGND VGND VPWR VPWR _5114_/Y sky130_fd_sc_hd__nand2_2
XFILLER_57_349 VGND VGND VPWR VPWR sky130_fd_sc_hd__decap_3
XFILLER_69_187 VGND VGND VPWR VPWR sky130_fd_sc_hd__decap_3
XFILLER_84_135 VGND VGND VPWR VPWR sky130_fd_sc_hd__decap_3
XFILLER_85_647 VGND VGND VPWR VPWR sky130_fd_sc_hd__decap_3
X_5045_ _6988_/Q _5045_/B VGND VGND VPWR VPWR _5045_/X sky130_fd_sc_hd__or2_2
XFILLER_27_39 VGND VGND VPWR VPWR sky130_fd_sc_hd__decap_3
XFILLER_84_168 VGND VGND VPWR VPWR sky130_fd_sc_hd__decap_3
XFILLER_25_202 VGND VGND VPWR VPWR sky130_fd_sc_hd__decap_3
XFILLER_53_511 VGND VGND VPWR VPWR sky130_fd_sc_hd__decap_3
XFILLER_53_522 VGND VGND VPWR VPWR sky130_fd_sc_hd__fill_2
XFILLER_65_360 VGND VGND VPWR VPWR sky130_fd_sc_hd__decap_3
XFILLER_65_393 VGND VGND VPWR VPWR sky130_fd_sc_hd__decap_3
XFILLER_25_246 VGND VGND VPWR VPWR sky130_fd_sc_hd__fill_2
XFILLER_80_330 VGND VGND VPWR VPWR sky130_fd_sc_hd__fill_2
X_6996_ _7403_/CLK _6996_/D _6276_/Y VGND VGND VPWR VPWR _6996_/Q sky130_fd_sc_hd__dfrtp_2
XFILLER_25_279 VGND VGND VPWR VPWR sky130_fd_sc_hd__fill_1
XFILLER_43_38 VGND VGND VPWR VPWR sky130_fd_sc_hd__fill_2
XFILLER_21_452 VGND VGND VPWR VPWR sky130_fd_sc_hd__decap_3
X_4829_ _4948_/A _4829_/B VGND VGND VPWR VPWR _4829_/Y sky130_fd_sc_hd__nor2_2
XFILLER_4_106 VGND VGND VPWR VPWR sky130_fd_sc_hd__decap_3
XFILLER_111_6 VGND VGND VPWR VPWR sky130_fd_sc_hd__decap_3
XFILLER_4_139 VGND VGND VPWR VPWR sky130_fd_sc_hd__fill_1
XFILLER_108_53 VGND VGND VPWR VPWR sky130_fd_sc_hd__decap_3
XFILLER_108_97 VGND VGND VPWR VPWR sky130_fd_sc_hd__decap_3
XFILLER_88_430 VGND VGND VPWR VPWR sky130_fd_sc_hd__decap_3
XFILLER_0_356 VGND VGND VPWR VPWR sky130_fd_sc_hd__decap_3
XFILLER_102_251 VGND VGND VPWR VPWR sky130_fd_sc_hd__fill_1
XFILLER_102_262 VGND VGND VPWR VPWR sky130_fd_sc_hd__decap_3
XFILLER_102_295 VGND VGND VPWR VPWR sky130_fd_sc_hd__decap_3
XFILLER_75_113 VGND VGND VPWR VPWR sky130_fd_sc_hd__decap_3
XFILLER_76_636 VGND VGND VPWR VPWR sky130_fd_sc_hd__decap_3
XFILLER_76_669 VGND VGND VPWR VPWR sky130_fd_sc_hd__decap_3
XFILLER_84_12 VGND VGND VPWR VPWR sky130_fd_sc_hd__decap_3
XFILLER_29_541 VGND VGND VPWR VPWR sky130_fd_sc_hd__decap_3
XFILLER_63_308 VGND VGND VPWR VPWR sky130_fd_sc_hd__fill_2
XFILLER_75_157 VGND VGND VPWR VPWR sky130_fd_sc_hd__decap_3
XFILLER_91_617 VGND VGND VPWR VPWR sky130_fd_sc_hd__decap_3
XFILLER_84_67 VGND VGND VPWR VPWR sky130_fd_sc_hd__fill_2
XFILLER_90_127 VGND VGND VPWR VPWR sky130_fd_sc_hd__decap_3
XFILLER_90_138 VGND VGND VPWR VPWR sky130_fd_sc_hd__fill_2
Xplace319 _4418_/A2 VGND VGND VPWR VPWR _4422_/A2 sky130_fd_sc_hd__buf_2
Xplace308 _5020_/A VGND VGND VPWR VPWR _4814_/A sky130_fd_sc_hd__buf_2
XFILLER_16_235 VGND VGND VPWR VPWR sky130_fd_sc_hd__decap_3
XFILLER_17_72 VGND VGND VPWR VPWR sky130_fd_sc_hd__decap_3
XFILLER_16_279 VGND VGND VPWR VPWR sky130_fd_sc_hd__fill_1
XFILLER_31_205 VGND VGND VPWR VPWR sky130_fd_sc_hd__decap_3
XFILLER_12_430 VGND VGND VPWR VPWR sky130_fd_sc_hd__decap_3
XFILLER_31_249 VGND VGND VPWR VPWR sky130_fd_sc_hd__decap_3
XFILLER_71_396 VGND VGND VPWR VPWR sky130_fd_sc_hd__decap_3
XTAP_TAPCELL_ROW_42_756 VGND VPWR sky130_fd_sc_hd__tapvpwrvgnd_1
XTAP_TAPCELL_ROW_14_425 VGND VPWR sky130_fd_sc_hd__tapvpwrvgnd_1
XTAP_TAPCELL_ROW_14_414 VGND VPWR sky130_fd_sc_hd__tapvpwrvgnd_1
XFILLER_33_60 VGND VGND VPWR VPWR sky130_fd_sc_hd__decap_3
XFILLER_76_9 VGND VGND VPWR VPWR sky130_fd_sc_hd__decap_3
XFILLER_8_445 VGND VGND VPWR VPWR sky130_fd_sc_hd__decap_3
XFILLER_113_505 VGND VGND VPWR VPWR sky130_fd_sc_hd__decap_3
XFILLER_4_651 VGND VGND VPWR VPWR sky130_fd_sc_hd__decap_3
XTAP_TAPCELL_ROW_113_1608 VGND VPWR sky130_fd_sc_hd__tapvpwrvgnd_1
XFILLER_113_516 VGND VGND VPWR VPWR sky130_fd_sc_hd__fill_2
XFILLER_113_538 VGND VGND VPWR VPWR sky130_fd_sc_hd__decap_3
XFILLER_4_684 VGND VGND VPWR VPWR sky130_fd_sc_hd__decap_3
XFILLER_79_430 VGND VGND VPWR VPWR sky130_fd_sc_hd__decap_3
XFILLER_79_452 VGND VGND VPWR VPWR sky130_fd_sc_hd__fill_1
XFILLER_67_603 VGND VGND VPWR VPWR sky130_fd_sc_hd__decap_3
XFILLER_66_135 VGND VGND VPWR VPWR sky130_fd_sc_hd__decap_3
XFILLER_67_647 VGND VGND VPWR VPWR sky130_fd_sc_hd__decap_3
XFILLER_94_433 VGND VGND VPWR VPWR sky130_fd_sc_hd__fill_1
XFILLER_66_168 VGND VGND VPWR VPWR sky130_fd_sc_hd__decap_3
XFILLER_82_628 VGND VGND VPWR VPWR sky130_fd_sc_hd__decap_3
XFILLER_75_691 VGND VGND VPWR VPWR sky130_fd_sc_hd__fill_1
XFILLER_81_116 VGND VGND VPWR VPWR sky130_fd_sc_hd__decap_3
XFILLER_35_555 VGND VGND VPWR VPWR sky130_fd_sc_hd__decap_3
XFILLER_47_393 VGND VGND VPWR VPWR sky130_fd_sc_hd__decap_3
XFILLER_81_149 VGND VGND VPWR VPWR sky130_fd_sc_hd__decap_3
X_6850_ _6946_/CLK _6850_/D VGND VGND VPWR VPWR _6850_/Q sky130_fd_sc_hd__dfxtp_2
XFILLER_50_525 VGND VGND VPWR VPWR sky130_fd_sc_hd__decap_3
XFILLER_62_374 VGND VGND VPWR VPWR sky130_fd_sc_hd__decap_3
XFILLER_90_672 VGND VGND VPWR VPWR sky130_fd_sc_hd__decap_3
X_6781_ _6972_/CLK _6781_/D VGND VGND VPWR VPWR _6781_/Q sky130_fd_sc_hd__dfxtp_2
XPHY_EDGE_ROW_8_Right_8 VGND VGND VPWR VPWR sky130_fd_sc_hd__decap_3
XFILLER_22_249 VGND VGND VPWR VPWR sky130_fd_sc_hd__decap_3
XFILLER_62_396 VGND VGND VPWR VPWR sky130_fd_sc_hd__decap_3
X_3993_ _4467_/B _3919_/X _3991_/X _3992_/Y VGND VGND VPWR VPWR _3993_/X sky130_fd_sc_hd__a31o_2
XFILLER_15_290 VGND VGND VPWR VPWR sky130_fd_sc_hd__decap_3
XFILLER_30_271 VGND VGND VPWR VPWR sky130_fd_sc_hd__decap_3
X_5663_ _5663_/A _5663_/B _5663_/C _5663_/D VGND VGND VPWR VPWR _5664_/D sky130_fd_sc_hd__nor4_2
XTAP_TAPCELL_ROW_79_1205 VGND VPWR sky130_fd_sc_hd__tapvpwrvgnd_1
X_7402_ _7402_/CLK _7402_/D _6682_/Y VGND VGND VPWR VPWR _7402_/Q sky130_fd_sc_hd__dfrtp_2
X_4614_ _4614_/A _4614_/B _4614_/C _5113_/A VGND VGND VPWR VPWR _4614_/X sky130_fd_sc_hd__and4_4
XFILLER_116_321 VGND VGND VPWR VPWR sky130_fd_sc_hd__decap_3
X_7333_ _7368_/CLK _7333_/D _6613_/Y VGND VGND VPWR VPWR _7333_/Q sky130_fd_sc_hd__dfrtp_2
XFILLER_116_365 VGND VGND VPWR VPWR sky130_fd_sc_hd__decap_3
X_7264_ _7266_/CLK _7264_/D _6544_/Y VGND VGND VPWR VPWR _7264_/Q sky130_fd_sc_hd__dfrtp_2
X_4476_ _4476_/A0 _7309_/Q _4488_/S VGND VGND VPWR VPWR _7341_/D sky130_fd_sc_hd__mux2_2
X_7195_ _7312_/CLK _7195_/D _6475_/Y VGND VGND VPWR VPWR _7195_/Q sky130_fd_sc_hd__dfrtp_2
X_3427_ _3527_/A _3427_/B VGND VGND VPWR VPWR _3508_/A sky130_fd_sc_hd__nand2b_2
XPHY_EDGE_ROW_39_Right_39 VGND VGND VPWR VPWR sky130_fd_sc_hd__decap_3
XFILLER_112_560 VGND VGND VPWR VPWR sky130_fd_sc_hd__decap_3
XFILLER_38_27 VGND VGND VPWR VPWR sky130_fd_sc_hd__fill_1
XFILLER_58_625 VGND VGND VPWR VPWR sky130_fd_sc_hd__decap_3
XFILLER_97_260 VGND VGND VPWR VPWR sky130_fd_sc_hd__decap_3
X_3358_ wire568/X _3469_/B _3449_/A _3365_/A VGND VGND VPWR VPWR _3358_/X sky130_fd_sc_hd__o211a_4
XFILLER_85_422 VGND VGND VPWR VPWR sky130_fd_sc_hd__decap_3
XFILLER_85_444 VGND VGND VPWR VPWR sky130_fd_sc_hd__decap_3
XFILLER_97_293 VGND VGND VPWR VPWR sky130_fd_sc_hd__decap_3
Xhold1101 _7303_/Q VGND VGND VPWR VPWR _4554_/A sky130_fd_sc_hd__dlygate4sd3_1
Xhold1112 _7245_/Q VGND VGND VPWR VPWR _5165_/A sky130_fd_sc_hd__dlygate4sd3_1
Xhold1123 _7327_/Q VGND VGND VPWR VPWR _4505_/A0 sky130_fd_sc_hd__dlygate4sd3_1
XFILLER_58_669 VGND VGND VPWR VPWR sky130_fd_sc_hd__decap_3
XFILLER_73_617 VGND VGND VPWR VPWR sky130_fd_sc_hd__decap_3
XFILLER_85_455 VGND VGND VPWR VPWR sky130_fd_sc_hd__decap_3
XFILLER_85_477 VGND VGND VPWR VPWR sky130_fd_sc_hd__decap_3
Xhold1134 _7253_/Q VGND VGND VPWR VPWR _5126_/A0 sky130_fd_sc_hd__dlygate4sd3_1
Xhold1145 _7291_/Q VGND VGND VPWR VPWR _4579_/A sky130_fd_sc_hd__dlygate4sd3_1
Xhold1156 _7177_/Q VGND VGND VPWR VPWR _5306_/A0 sky130_fd_sc_hd__dlygate4sd3_1
Xhold1167 _7312_/Q VGND VGND VPWR VPWR _4534_/A0 sky130_fd_sc_hd__dlygate4sd3_1
XFILLER_38_360 VGND VGND VPWR VPWR sky130_fd_sc_hd__decap_3
XFILLER_38_382 VGND VGND VPWR VPWR sky130_fd_sc_hd__decap_3
Xhold1178 _7230_/Q VGND VGND VPWR VPWR _5196_/A sky130_fd_sc_hd__dlygate4sd3_1
Xhold1189 _7247_/Q VGND VGND VPWR VPWR _5159_/A0 sky130_fd_sc_hd__dlygate4sd3_1
X_5028_ _5028_/A0 _5027_/X _5028_/S VGND VGND VPWR VPWR _7260_/D sky130_fd_sc_hd__mux2_2
XFILLER_26_544 VGND VGND VPWR VPWR sky130_fd_sc_hd__fill_1
XFILLER_54_15 VGND VGND VPWR VPWR sky130_fd_sc_hd__decap_3
XFILLER_54_48 VGND VGND VPWR VPWR sky130_fd_sc_hd__fill_1
XFILLER_65_190 VGND VGND VPWR VPWR sky130_fd_sc_hd__decap_3
XFILLER_81_650 VGND VGND VPWR VPWR sky130_fd_sc_hd__decap_3
XFILLER_13_205 VGND VGND VPWR VPWR sky130_fd_sc_hd__decap_3
XFILLER_26_566 VGND VGND VPWR VPWR sky130_fd_sc_hd__decap_3
XFILLER_26_577 VGND VGND VPWR VPWR sky130_fd_sc_hd__fill_2
XFILLER_54_59 VGND VGND VPWR VPWR sky130_fd_sc_hd__decap_3
XFILLER_110_21 VGND VGND VPWR VPWR sky130_fd_sc_hd__decap_3
XFILLER_110_32 VGND VGND VPWR VPWR sky130_fd_sc_hd__decap_3
XFILLER_13_249 VGND VGND VPWR VPWR sky130_fd_sc_hd__decap_3
XFILLER_53_396 VGND VGND VPWR VPWR sky130_fd_sc_hd__decap_3
XFILLER_80_193 VGND VGND VPWR VPWR sky130_fd_sc_hd__decap_3
X_6979_ _7265_/CLK _6979_/D _6259_/Y VGND VGND VPWR VPWR _6979_/Q sky130_fd_sc_hd__dfrtp_2
XPHY_EDGE_ROW_48_Right_48 VGND VGND VPWR VPWR sky130_fd_sc_hd__decap_3
XFILLER_110_65 VGND VGND VPWR VPWR sky130_fd_sc_hd__decap_3
XFILLER_70_58 VGND VGND VPWR VPWR sky130_fd_sc_hd__decap_3
XFILLER_5_426 VGND VGND VPWR VPWR sky130_fd_sc_hd__decap_3
XFILLER_107_354 VGND VGND VPWR VPWR sky130_fd_sc_hd__decap_3
XFILLER_79_23 VGND VGND VPWR VPWR sky130_fd_sc_hd__decap_3
XFILLER_79_78 VGND VGND VPWR VPWR sky130_fd_sc_hd__decap_3
XPHY_EDGE_ROW_57_Right_57 VGND VGND VPWR VPWR sky130_fd_sc_hd__decap_3
XFILLER_1_643 VGND VGND VPWR VPWR sky130_fd_sc_hd__decap_3
Xhold990 _7044_/Q VGND VGND VPWR VPWR hold990/X sky130_fd_sc_hd__dlygate4sd3_1
XFILLER_1_676 VGND VGND VPWR VPWR sky130_fd_sc_hd__decap_3
XFILLER_49_603 VGND VGND VPWR VPWR sky130_fd_sc_hd__decap_3
XFILLER_0_164 VGND VGND VPWR VPWR sky130_fd_sc_hd__decap_3
XFILLER_0_197 VGND VGND VPWR VPWR sky130_fd_sc_hd__fill_2
XFILLER_48_102 VGND VGND VPWR VPWR sky130_fd_sc_hd__decap_3
XFILLER_49_647 VGND VGND VPWR VPWR sky130_fd_sc_hd__decap_3
XFILLER_76_411 VGND VGND VPWR VPWR sky130_fd_sc_hd__decap_3
XFILLER_76_433 VGND VGND VPWR VPWR sky130_fd_sc_hd__decap_3
XFILLER_88_293 VGND VGND VPWR VPWR sky130_fd_sc_hd__decap_3
XFILLER_95_55 VGND VGND VPWR VPWR sky130_fd_sc_hd__fill_1
XFILLER_95_66 VGND VGND VPWR VPWR sky130_fd_sc_hd__decap_3
XFILLER_76_466 VGND VGND VPWR VPWR sky130_fd_sc_hd__decap_3
XFILLER_76_477 VGND VGND VPWR VPWR sky130_fd_sc_hd__fill_2
XFILLER_28_82 VGND VGND VPWR VPWR sky130_fd_sc_hd__fill_2
XFILLER_57_691 VGND VGND VPWR VPWR sky130_fd_sc_hd__fill_1
XFILLER_63_105 VGND VGND VPWR VPWR sky130_fd_sc_hd__decap_3
XFILLER_64_628 VGND VGND VPWR VPWR sky130_fd_sc_hd__decap_3
XTAP_TAPCELL_ROW_47_815 VGND VPWR sky130_fd_sc_hd__tapvpwrvgnd_1
XFILLER_29_393 VGND VGND VPWR VPWR sky130_fd_sc_hd__decap_3
XFILLER_44_341 VGND VGND VPWR VPWR sky130_fd_sc_hd__fill_1
XFILLER_91_447 VGND VGND VPWR VPWR sky130_fd_sc_hd__fill_1
XFILLER_44_374 VGND VGND VPWR VPWR sky130_fd_sc_hd__decap_3
XFILLER_72_672 VGND VGND VPWR VPWR sky130_fd_sc_hd__decap_3
XTAP_TAPCELL_ROW_63_1006 VGND VPWR sky130_fd_sc_hd__tapvpwrvgnd_1
XPHY_EDGE_ROW_66_Right_66 VGND VGND VPWR VPWR sky130_fd_sc_hd__decap_3
XFILLER_44_70 VGND VGND VPWR VPWR sky130_fd_sc_hd__decap_3
XFILLER_71_193 VGND VGND VPWR VPWR sky130_fd_sc_hd__decap_3
XTAP_TAPCELL_ROW_27_572 VGND VPWR sky130_fd_sc_hd__tapvpwrvgnd_1
XFILLER_12_271 VGND VGND VPWR VPWR sky130_fd_sc_hd__decap_3
XFILLER_8_253 VGND VGND VPWR VPWR sky130_fd_sc_hd__decap_3
XFILLER_8_286 VGND VGND VPWR VPWR sky130_fd_sc_hd__decap_3
Xoutput517 _5643_/X VGND VGND VPWR VPWR instruction_out[5] sky130_fd_sc_hd__clkdlybuf4s25_1
Xoutput506 _3449_/A VGND VGND VPWR VPWR instruction_out[22] sky130_fd_sc_hd__clkdlybuf4s25_1
XPHY_EDGE_ROW_75_Right_75 VGND VGND VPWR VPWR sky130_fd_sc_hd__decap_3
XFILLER_5_42 VGND VGND VPWR VPWR sky130_fd_sc_hd__decap_3
Xoutput539 place451/X VGND VGND VPWR VPWR pc_out[25] sky130_fd_sc_hd__clkdlybuf4s25_1
Xoutput528 _6992_/Q VGND VGND VPWR VPWR pc_out[15] sky130_fd_sc_hd__clkdlybuf4s25_1
X_4330_ _5057_/B _4330_/B VGND VGND VPWR VPWR _4619_/B sky130_fd_sc_hd__or2_2
XTAP_TAPCELL_ROW_74_1135 VGND VPWR sky130_fd_sc_hd__tapvpwrvgnd_1
XFILLER_99_536 VGND VGND VPWR VPWR sky130_fd_sc_hd__decap_3
XFILLER_99_514 VGND VGND VPWR VPWR sky130_fd_sc_hd__decap_3
XFILLER_113_324 VGND VGND VPWR VPWR sky130_fd_sc_hd__decap_3
XFILLER_113_346 VGND VGND VPWR VPWR sky130_fd_sc_hd__decap_3
XFILLER_113_357 VGND VGND VPWR VPWR sky130_fd_sc_hd__decap_3
XFILLER_5_75 VGND VGND VPWR VPWR sky130_fd_sc_hd__decap_3
X_4261_ _7358_/Q _4261_/A2 _4261_/B1 _7166_/Q _4248_/A VGND VGND VPWR VPWR _4261_/X
+ sky130_fd_sc_hd__a221o_2
XFILLER_99_569 VGND VGND VPWR VPWR sky130_fd_sc_hd__decap_3
XFILLER_101_508 VGND VGND VPWR VPWR sky130_fd_sc_hd__decap_3
XFILLER_67_433 VGND VGND VPWR VPWR sky130_fd_sc_hd__fill_1
X_4192_ _4637_/B _4637_/C VGND VGND VPWR VPWR _4380_/A sky130_fd_sc_hd__and2_2
XFILLER_27_308 VGND VGND VPWR VPWR sky130_fd_sc_hd__decap_3
XFILLER_39_157 VGND VGND VPWR VPWR sky130_fd_sc_hd__decap_3
XFILLER_55_606 VGND VGND VPWR VPWR sky130_fd_sc_hd__decap_3
XFILLER_55_617 VGND VGND VPWR VPWR sky130_fd_sc_hd__decap_3
XFILLER_67_444 VGND VGND VPWR VPWR sky130_fd_sc_hd__decap_3
XFILLER_67_466 VGND VGND VPWR VPWR sky130_fd_sc_hd__decap_3
XFILLER_94_241 VGND VGND VPWR VPWR sky130_fd_sc_hd__fill_2
XFILLER_54_127 VGND VGND VPWR VPWR sky130_fd_sc_hd__fill_1
XFILLER_82_414 VGND VGND VPWR VPWR sky130_fd_sc_hd__fill_1
XFILLER_94_274 VGND VGND VPWR VPWR sky130_fd_sc_hd__decap_3
XPHY_EDGE_ROW_84_Right_84 VGND VGND VPWR VPWR sky130_fd_sc_hd__decap_3
XPHY_EDGE_ROW_19_Left_136 VGND VGND VPWR VPWR sky130_fd_sc_hd__decap_3
XFILLER_47_190 VGND VGND VPWR VPWR sky130_fd_sc_hd__decap_3
XFILLER_54_138 VGND VGND VPWR VPWR sky130_fd_sc_hd__fill_2
X_6902_ _6976_/CLK _6902_/D VGND VGND VPWR VPWR _6902_/Q sky130_fd_sc_hd__dfxtp_2
XFILLER_35_352 VGND VGND VPWR VPWR sky130_fd_sc_hd__decap_3
X_6833_ _6978_/CLK _6833_/D VGND VGND VPWR VPWR _6833_/Q sky130_fd_sc_hd__dfxtp_2
XTAP_TAPCELL_ROW_85_1275 VGND VPWR sky130_fd_sc_hd__tapvpwrvgnd_1
XFILLER_24_29 VGND VGND VPWR VPWR sky130_fd_sc_hd__fill_1
XFILLER_35_396 VGND VGND VPWR VPWR sky130_fd_sc_hd__decap_3
X_6764_ _6976_/CLK _6764_/D VGND VGND VPWR VPWR _6764_/Q sky130_fd_sc_hd__dfxtp_2
X_6695_ _7384_/CLK _6695_/D VGND VGND VPWR VPWR _6695_/Q sky130_fd_sc_hd__dfxtp_2
X_5715_ _7363_/Q hold937/X _5737_/S VGND VGND VPWR VPWR _6707_/D sky130_fd_sc_hd__mux2_2
X_5646_ _5646_/A VGND VGND VPWR VPWR _5646_/Y sky130_fd_sc_hd__inv_2
XPHY_EDGE_ROW_28_Left_145 VGND VGND VPWR VPWR sky130_fd_sc_hd__decap_3
XFILLER_108_118 VGND VGND VPWR VPWR sky130_fd_sc_hd__decap_3
XFILLER_40_39 VGND VGND VPWR VPWR sky130_fd_sc_hd__fill_2
XPHY_EDGE_ROW_93_Right_93 VGND VGND VPWR VPWR sky130_fd_sc_hd__decap_3
X_5577_ _5577_/A0 _5038_/X _5595_/B VGND VGND VPWR VPWR _7040_/D sky130_fd_sc_hd__mux2_2
XFILLER_104_302 VGND VGND VPWR VPWR sky130_fd_sc_hd__fill_1
XFILLER_2_407 VGND VGND VPWR VPWR sky130_fd_sc_hd__decap_3
X_7316_ clkload3/A _7316_/D _6596_/Y VGND VGND VPWR VPWR _7316_/Q sky130_fd_sc_hd__dfrtp_2
X_4528_ _4528_/A _4528_/B VGND VGND VPWR VPWR _7315_/D sky130_fd_sc_hd__or2_2
XFILLER_104_324 VGND VGND VPWR VPWR sky130_fd_sc_hd__decap_3
XFILLER_49_15 VGND VGND VPWR VPWR sky130_fd_sc_hd__decap_3
XFILLER_6_9 VGND VGND VPWR VPWR sky130_fd_sc_hd__decap_3
X_7247_ _7312_/CLK _7247_/D _6527_/Y VGND VGND VPWR VPWR _7247_/Q sky130_fd_sc_hd__dfrtp_2
X_4459_ _4040_/Y _4457_/X _4458_/X _3366_/X VGND VGND VPWR VPWR _5655_/B sky130_fd_sc_hd__o211a_2
XFILLER_104_368 VGND VGND VPWR VPWR sky130_fd_sc_hd__decap_3
XFILLER_49_48 VGND VGND VPWR VPWR sky130_fd_sc_hd__decap_3
XFILLER_105_21 VGND VGND VPWR VPWR sky130_fd_sc_hd__decap_3
X_7178_ _7402_/CLK _7178_/D _6458_/Y VGND VGND VPWR VPWR _7178_/Q sky130_fd_sc_hd__dfrtp_2
XFILLER_105_54 VGND VGND VPWR VPWR sky130_fd_sc_hd__fill_2
XFILLER_46_617 VGND VGND VPWR VPWR sky130_fd_sc_hd__decap_3
XPHY_EDGE_ROW_37_Left_154 VGND VGND VPWR VPWR sky130_fd_sc_hd__decap_3
XFILLER_45_116 VGND VGND VPWR VPWR sky130_fd_sc_hd__decap_3
XFILLER_58_477 VGND VGND VPWR VPWR sky130_fd_sc_hd__decap_3
XFILLER_39_691 VGND VGND VPWR VPWR sky130_fd_sc_hd__fill_1
XFILLER_65_69 VGND VGND VPWR VPWR sky130_fd_sc_hd__decap_3
XFILLER_73_447 VGND VGND VPWR VPWR sky130_fd_sc_hd__fill_1
XFILLER_26_352 VGND VGND VPWR VPWR sky130_fd_sc_hd__decap_3
XFILLER_26_363 VGND VGND VPWR VPWR sky130_fd_sc_hd__fill_1
XFILLER_54_672 VGND VGND VPWR VPWR sky130_fd_sc_hd__decap_3
XFILLER_60_108 VGND VGND VPWR VPWR sky130_fd_sc_hd__decap_3
XFILLER_26_385 VGND VGND VPWR VPWR sky130_fd_sc_hd__decap_3
XFILLER_81_24 VGND VGND VPWR VPWR sky130_fd_sc_hd__decap_3
XTAP_TAPCELL_ROW_24_542 VGND VPWR sky130_fd_sc_hd__tapvpwrvgnd_1
XFILLER_14_62 VGND VGND VPWR VPWR sky130_fd_sc_hd__decap_3
XFILLER_81_79 VGND VGND VPWR VPWR sky130_fd_sc_hd__decap_3
XTAP_TAPCELL_ROW_52_873 VGND VPWR sky130_fd_sc_hd__tapvpwrvgnd_1
XPHY_EDGE_ROW_46_Left_163 VGND VGND VPWR VPWR sky130_fd_sc_hd__decap_3
XFILLER_108_663 VGND VGND VPWR VPWR sky130_fd_sc_hd__decap_3
XFILLER_30_50 VGND VGND VPWR VPWR sky130_fd_sc_hd__decap_3
XFILLER_5_234 VGND VGND VPWR VPWR sky130_fd_sc_hd__fill_1
XFILLER_30_83 VGND VGND VPWR VPWR sky130_fd_sc_hd__fill_1
XFILLER_30_94 VGND VGND VPWR VPWR sky130_fd_sc_hd__decap_3
XFILLER_39_9 VGND VGND VPWR VPWR sky130_fd_sc_hd__decap_3
XFILLER_96_506 VGND VGND VPWR VPWR sky130_fd_sc_hd__decap_3
XFILLER_96_528 VGND VGND VPWR VPWR sky130_fd_sc_hd__decap_3
XPHY_EDGE_ROW_55_Left_172 VGND VGND VPWR VPWR sky130_fd_sc_hd__decap_3
XFILLER_110_338 VGND VGND VPWR VPWR sky130_fd_sc_hd__decap_3
XFILLER_49_422 VGND VGND VPWR VPWR sky130_fd_sc_hd__decap_3
XFILLER_49_455 VGND VGND VPWR VPWR sky130_fd_sc_hd__decap_3
XFILLER_36_116 VGND VGND VPWR VPWR sky130_fd_sc_hd__decap_3
XFILLER_49_477 VGND VGND VPWR VPWR sky130_fd_sc_hd__decap_3
XFILLER_76_285 VGND VGND VPWR VPWR sky130_fd_sc_hd__decap_3
XFILLER_17_330 VGND VGND VPWR VPWR sky130_fd_sc_hd__decap_3
XFILLER_29_190 VGND VGND VPWR VPWR sky130_fd_sc_hd__decap_3
XFILLER_36_149 VGND VGND VPWR VPWR sky130_fd_sc_hd__decap_3
XFILLER_64_469 VGND VGND VPWR VPWR sky130_fd_sc_hd__decap_3
XFILLER_17_363 VGND VGND VPWR VPWR sky130_fd_sc_hd__decap_3
XFILLER_45_650 VGND VGND VPWR VPWR sky130_fd_sc_hd__decap_3
XFILLER_45_661 VGND VGND VPWR VPWR sky130_fd_sc_hd__decap_3
XFILLER_51_119 VGND VGND VPWR VPWR sky130_fd_sc_hd__decap_3
XFILLER_91_277 VGND VGND VPWR VPWR sky130_fd_sc_hd__decap_3
XFILLER_17_385 VGND VGND VPWR VPWR sky130_fd_sc_hd__decap_3
XFILLER_60_631 VGND VGND VPWR VPWR sky130_fd_sc_hd__decap_3
XFILLER_60_675 VGND VGND VPWR VPWR sky130_fd_sc_hd__decap_3
X_3830_ _6860_/Q _3883_/A2 _3913_/B1 _6852_/Q _3829_/X VGND VGND VPWR VPWR _3830_/X
+ sky130_fd_sc_hd__a221o_2
XPHY_EDGE_ROW_64_Left_181 VGND VGND VPWR VPWR sky130_fd_sc_hd__decap_3
XFILLER_72_3 VGND VGND VPWR VPWR sky130_fd_sc_hd__decap_3
X_6480_ _6644_/A VGND VGND VPWR VPWR _6480_/Y sky130_fd_sc_hd__inv_2
X_3692_ _6715_/Q _3767_/A2 _3767_/B1 _6893_/Q _3691_/X VGND VGND VPWR VPWR _3692_/X
+ sky130_fd_sc_hd__a221o_2
XFILLER_114_622 VGND VGND VPWR VPWR sky130_fd_sc_hd__decap_3
X_5362_ _3378_/A _5646_/A _5362_/C VGND VGND VPWR VPWR _5396_/S sky130_fd_sc_hd__and3b_2
X_7101_ clkload7/A _7101_/D _6381_/Y VGND VGND VPWR VPWR _7101_/Q sky130_fd_sc_hd__dfrtp_2
X_4313_ _4376_/A _4364_/A _4364_/B _4313_/D VGND VGND VPWR VPWR _4315_/A sky130_fd_sc_hd__or4_4
XPHY_EDGE_ROW_73_Left_190 VGND VGND VPWR VPWR sky130_fd_sc_hd__decap_3
XFILLER_99_322 VGND VGND VPWR VPWR sky130_fd_sc_hd__decap_3
XFILLER_113_143 VGND VGND VPWR VPWR sky130_fd_sc_hd__decap_3
XFILLER_114_666 VGND VGND VPWR VPWR sky130_fd_sc_hd__decap_3
X_7032_ _7352_/CLK _7032_/D _6312_/Y VGND VGND VPWR VPWR _7032_/Q sky130_fd_sc_hd__dfrtp_2
XFILLER_99_366 VGND VGND VPWR VPWR sky130_fd_sc_hd__decap_3
XFILLER_101_316 VGND VGND VPWR VPWR sky130_fd_sc_hd__decap_3
XFILLER_113_187 VGND VGND VPWR VPWR sky130_fd_sc_hd__decap_3
X_4244_ _7293_/Q _4517_/S VGND VGND VPWR VPWR _4244_/X sky130_fd_sc_hd__and2_2
XFILLER_99_399 VGND VGND VPWR VPWR sky130_fd_sc_hd__decap_3
XFILLER_95_561 VGND VGND VPWR VPWR sky130_fd_sc_hd__decap_3
X_4175_ _7328_/Q _3964_/S _4248_/A _4174_/X VGND VGND VPWR VPWR _4175_/X sky130_fd_sc_hd__a211o_2
XFILLER_27_105 VGND VGND VPWR VPWR sky130_fd_sc_hd__fill_2
XFILLER_27_116 VGND VGND VPWR VPWR sky130_fd_sc_hd__decap_3
XFILLER_28_617 VGND VGND VPWR VPWR sky130_fd_sc_hd__fill_2
XFILLER_82_200 VGND VGND VPWR VPWR sky130_fd_sc_hd__decap_3
XFILLER_55_458 VGND VGND VPWR VPWR sky130_fd_sc_hd__decap_3
XFILLER_35_17 VGND VGND VPWR VPWR sky130_fd_sc_hd__fill_2
XFILLER_36_683 VGND VGND VPWR VPWR sky130_fd_sc_hd__decap_3
XFILLER_51_620 VGND VGND VPWR VPWR sky130_fd_sc_hd__decap_3
XFILLER_70_439 VGND VGND VPWR VPWR sky130_fd_sc_hd__decap_3
XFILLER_23_333 VGND VGND VPWR VPWR sky130_fd_sc_hd__decap_3
XFILLER_23_344 VGND VGND VPWR VPWR sky130_fd_sc_hd__decap_3
XFILLER_51_653 VGND VGND VPWR VPWR sky130_fd_sc_hd__decap_3
X_6816_ _6909_/CLK _6816_/D VGND VGND VPWR VPWR _6816_/Q sky130_fd_sc_hd__dfxtp_2
XFILLER_23_377 VGND VGND VPWR VPWR sky130_fd_sc_hd__decap_3
XFILLER_50_152 VGND VGND VPWR VPWR sky130_fd_sc_hd__decap_3
XFILLER_50_185 VGND VGND VPWR VPWR sky130_fd_sc_hd__decap_3
X_6747_ _6909_/CLK _6747_/D VGND VGND VPWR VPWR _6747_/Q sky130_fd_sc_hd__dfxtp_2
XTAP_TAPCELL_ROW_21_501 VGND VPWR sky130_fd_sc_hd__tapvpwrvgnd_1
XFILLER_109_405 VGND VGND VPWR VPWR sky130_fd_sc_hd__decap_3
XTAP_TAPCELL_ROW_98_1422 VGND VPWR sky130_fd_sc_hd__tapvpwrvgnd_1
X_6678_ _6684_/A VGND VGND VPWR VPWR _6678_/Y sky130_fd_sc_hd__inv_2
XTAP_TAPCELL_ROW_98_1433 VGND VPWR sky130_fd_sc_hd__tapvpwrvgnd_1
XFILLER_109_449 VGND VGND VPWR VPWR sky130_fd_sc_hd__decap_3
XFILLER_105_644 VGND VGND VPWR VPWR sky130_fd_sc_hd__decap_3
XFILLER_4_6 VGND VGND VPWR VPWR sky130_fd_sc_hd__decap_3
XFILLER_105_688 VGND VGND VPWR VPWR sky130_fd_sc_hd__decap_3
XFILLER_116_53 VGND VGND VPWR VPWR sky130_fd_sc_hd__decap_3
XFILLER_116_97 VGND VGND VPWR VPWR sky130_fd_sc_hd__decap_3
XFILLER_76_35 VGND VGND VPWR VPWR sky130_fd_sc_hd__decap_3
XFILLER_100_371 VGND VGND VPWR VPWR sky130_fd_sc_hd__decap_3
XFILLER_58_274 VGND VGND VPWR VPWR sky130_fd_sc_hd__decap_3
XTAP_TAPCELL_ROW_29_601 VGND VPWR sky130_fd_sc_hd__tapvpwrvgnd_1
XFILLER_18_127 VGND VGND VPWR VPWR sky130_fd_sc_hd__decap_3
XFILLER_18_149 VGND VGND VPWR VPWR sky130_fd_sc_hd__decap_3
XFILLER_46_436 VGND VGND VPWR VPWR sky130_fd_sc_hd__decap_3
XFILLER_58_296 VGND VGND VPWR VPWR sky130_fd_sc_hd__decap_3
XFILLER_73_222 VGND VGND VPWR VPWR sky130_fd_sc_hd__fill_2
XFILLER_92_12 VGND VGND VPWR VPWR sky130_fd_sc_hd__decap_3
XTAP_TAPCELL_ROW_57_932 VGND VPWR sky130_fd_sc_hd__tapvpwrvgnd_1
XFILLER_73_266 VGND VGND VPWR VPWR sky130_fd_sc_hd__decap_3
XTAP_TAPCELL_ROW_107_1540 VGND VPWR sky130_fd_sc_hd__tapvpwrvgnd_1
XFILLER_73_299 VGND VGND VPWR VPWR sky130_fd_sc_hd__decap_3
XFILLER_25_72 VGND VGND VPWR VPWR sky130_fd_sc_hd__decap_3
XFILLER_42_642 VGND VGND VPWR VPWR sky130_fd_sc_hd__fill_2
XFILLER_42_653 VGND VGND VPWR VPWR sky130_fd_sc_hd__decap_3
XFILLER_14_377 VGND VGND VPWR VPWR sky130_fd_sc_hd__decap_3
XFILLER_42_686 VGND VGND VPWR VPWR sky130_fd_sc_hd__decap_3
XFILLER_41_60 VGND VGND VPWR VPWR sky130_fd_sc_hd__decap_3
XFILLER_41_93 VGND VGND VPWR VPWR sky130_fd_sc_hd__decap_3
XFILLER_111_603 VGND VGND VPWR VPWR sky130_fd_sc_hd__decap_3
XFILLER_96_303 VGND VGND VPWR VPWR sky130_fd_sc_hd__decap_3
XTAP_TAPCELL_ROW_71_1105 VGND VPWR sky130_fd_sc_hd__tapvpwrvgnd_1
XFILLER_111_647 VGND VGND VPWR VPWR sky130_fd_sc_hd__decap_3
XFILLER_37_6 VGND VGND VPWR VPWR sky130_fd_sc_hd__decap_3
XFILLER_69_528 VGND VGND VPWR VPWR sky130_fd_sc_hd__decap_3
XFILLER_110_124 VGND VGND VPWR VPWR sky130_fd_sc_hd__decap_3
XFILLER_2_32 VGND VGND VPWR VPWR sky130_fd_sc_hd__decap_3
XFILLER_110_168 VGND VGND VPWR VPWR sky130_fd_sc_hd__decap_3
XFILLER_2_65 VGND VGND VPWR VPWR sky130_fd_sc_hd__decap_3
XFILLER_64_200 VGND VGND VPWR VPWR sky130_fd_sc_hd__decap_3
XFILLER_77_561 VGND VGND VPWR VPWR sky130_fd_sc_hd__fill_1
XFILLER_77_583 VGND VGND VPWR VPWR sky130_fd_sc_hd__decap_3
XFILLER_37_425 VGND VGND VPWR VPWR sky130_fd_sc_hd__decap_3
XFILLER_64_211 VGND VGND VPWR VPWR sky130_fd_sc_hd__decap_3
XFILLER_77_594 VGND VGND VPWR VPWR sky130_fd_sc_hd__decap_3
XFILLER_92_531 VGND VGND VPWR VPWR sky130_fd_sc_hd__fill_1
XFILLER_18_672 VGND VGND VPWR VPWR sky130_fd_sc_hd__decap_3
XFILLER_52_417 VGND VGND VPWR VPWR sky130_fd_sc_hd__decap_3
XTAP_TAPCELL_ROW_69_1078 VGND VPWR sky130_fd_sc_hd__tapvpwrvgnd_1
XFILLER_17_160 VGND VGND VPWR VPWR sky130_fd_sc_hd__decap_3
XFILLER_33_620 VGND VGND VPWR VPWR sky130_fd_sc_hd__fill_2
XFILLER_52_439 VGND VGND VPWR VPWR sky130_fd_sc_hd__decap_3
X_4931_ _4931_/A _4931_/B VGND VGND VPWR VPWR _6996_/D sky130_fd_sc_hd__nor2_2
XFILLER_32_141 VGND VGND VPWR VPWR sky130_fd_sc_hd__decap_3
X_4862_ _4825_/B _4862_/B VGND VGND VPWR VPWR _7000_/D sky130_fd_sc_hd__and2b_2
XTAP_TAPCELL_ROW_82_1234 VGND VPWR sky130_fd_sc_hd__tapvpwrvgnd_1
XFILLER_20_303 VGND VGND VPWR VPWR sky130_fd_sc_hd__decap_3
XFILLER_60_483 VGND VGND VPWR VPWR sky130_fd_sc_hd__decap_3
X_6601_ _6637_/A VGND VGND VPWR VPWR _6601_/Y sky130_fd_sc_hd__inv_2
X_3813_ _3802_/X _3812_/X _3896_/B1 VGND VGND VPWR VPWR _3813_/Y sky130_fd_sc_hd__o21ai_2
X_4793_ _4793_/A0 _4792_/X _4901_/S VGND VGND VPWR VPWR _7274_/D sky130_fd_sc_hd__mux2_2
X_6532_ _6532_/A VGND VGND VPWR VPWR _6532_/Y sky130_fd_sc_hd__inv_2
X_3744_ _6728_/Q _3892_/A2 _3893_/B1 _6973_/Q VGND VGND VPWR VPWR _3744_/X sky130_fd_sc_hd__a22o_2
X_6463_ _6672_/A VGND VGND VPWR VPWR _6463_/Y sky130_fd_sc_hd__inv_2
X_6394_ _6553_/A VGND VGND VPWR VPWR _6394_/Y sky130_fd_sc_hd__inv_2
XTAP_TAPCELL_ROW_93_1363 VGND VPWR sky130_fd_sc_hd__tapvpwrvgnd_1
XFILLER_101_113 VGND VGND VPWR VPWR sky130_fd_sc_hd__decap_3
XFILLER_102_636 VGND VGND VPWR VPWR sky130_fd_sc_hd__decap_3
X_5276_ _5276_/A0 _5094_/X _5292_/S VGND VGND VPWR VPWR _7192_/D sky130_fd_sc_hd__mux2_2
XFILLER_102_669 VGND VGND VPWR VPWR sky130_fd_sc_hd__decap_3
X_7015_ clkload7/A _7015_/D _6295_/Y VGND VGND VPWR VPWR _7015_/Q sky130_fd_sc_hd__dfrtp_2
X_4227_ _7355_/Q _4337_/B _4334_/B1 _7163_/Q VGND VGND VPWR VPWR _4227_/X sky130_fd_sc_hd__a22o_2
XFILLER_28_447 VGND VGND VPWR VPWR sky130_fd_sc_hd__decap_3
X_4158_ _4158_/A _4158_/B VGND VGND VPWR VPWR _4920_/A sky130_fd_sc_hd__nand2_2
XFILLER_43_406 VGND VGND VPWR VPWR sky130_fd_sc_hd__decap_3
XFILLER_55_266 VGND VGND VPWR VPWR sky130_fd_sc_hd__decap_3
X_4089_ _7206_/Q _3962_/S _4196_/A2 _7398_/Q VGND VGND VPWR VPWR _4089_/X sky130_fd_sc_hd__a22o_2
XTAP_TAPCELL_ROW_54_902 VGND VPWR sky130_fd_sc_hd__tapvpwrvgnd_1
XFILLER_102_55 VGND VGND VPWR VPWR sky130_fd_sc_hd__decap_3
XFILLER_24_620 VGND VGND VPWR VPWR sky130_fd_sc_hd__decap_3
XFILLER_43_439 VGND VGND VPWR VPWR sky130_fd_sc_hd__fill_1
XFILLER_70_203 VGND VGND VPWR VPWR sky130_fd_sc_hd__decap_3
XFILLER_102_88 VGND VGND VPWR VPWR sky130_fd_sc_hd__decap_3
XFILLER_62_15 VGND VGND VPWR VPWR sky130_fd_sc_hd__decap_3
XFILLER_62_59 VGND VGND VPWR VPWR sky130_fd_sc_hd__decap_3
XFILLER_11_325 VGND VGND VPWR VPWR sky130_fd_sc_hd__decap_3
XTAP_TAPCELL_ROW_62_990 VGND VPWR sky130_fd_sc_hd__tapvpwrvgnd_1
XTAP_TAPCELL_ROW_102_1481 VGND VPWR sky130_fd_sc_hd__tapvpwrvgnd_1
XTAP_TAPCELL_ROW_102_1470 VGND VPWR sky130_fd_sc_hd__tapvpwrvgnd_1
XFILLER_109_202 VGND VGND VPWR VPWR sky130_fd_sc_hd__decap_3
XFILLER_7_329 VGND VGND VPWR VPWR sky130_fd_sc_hd__decap_3
XFILLER_109_246 VGND VGND VPWR VPWR sky130_fd_sc_hd__decap_3
XFILLER_11_30 VGND VGND VPWR VPWR sky130_fd_sc_hd__decap_3
XFILLER_11_63 VGND VGND VPWR VPWR sky130_fd_sc_hd__decap_3
XFILLER_105_452 VGND VGND VPWR VPWR sky130_fd_sc_hd__decap_3
XFILLER_11_96 VGND VGND VPWR VPWR sky130_fd_sc_hd__decap_3
XFILLER_87_12 VGND VGND VPWR VPWR sky130_fd_sc_hd__decap_3
XFILLER_105_474 VGND VGND VPWR VPWR sky130_fd_sc_hd__decap_3
XFILLER_78_303 VGND VGND VPWR VPWR sky130_fd_sc_hd__fill_1
XFILLER_78_336 VGND VGND VPWR VPWR sky130_fd_sc_hd__decap_3
XFILLER_66_509 VGND VGND VPWR VPWR sky130_fd_sc_hd__decap_3
XFILLER_78_347 VGND VGND VPWR VPWR sky130_fd_sc_hd__decap_3
XFILLER_46_200 VGND VGND VPWR VPWR sky130_fd_sc_hd__decap_3
XFILLER_59_572 VGND VGND VPWR VPWR sky130_fd_sc_hd__decap_3
XFILLER_101_691 VGND VGND VPWR VPWR sky130_fd_sc_hd__fill_1
XFILLER_46_233 VGND VGND VPWR VPWR sky130_fd_sc_hd__decap_3
XFILLER_74_542 VGND VGND VPWR VPWR sky130_fd_sc_hd__decap_3
XFILLER_74_553 VGND VGND VPWR VPWR sky130_fd_sc_hd__decap_3
XFILLER_34_428 VGND VGND VPWR VPWR sky130_fd_sc_hd__decap_3
XFILLER_36_60 VGND VGND VPWR VPWR sky130_fd_sc_hd__fill_1
XFILLER_36_82 VGND VGND VPWR VPWR sky130_fd_sc_hd__fill_2
XFILLER_61_214 VGND VGND VPWR VPWR sky130_fd_sc_hd__decap_3
XFILLER_61_225 VGND VGND VPWR VPWR sky130_fd_sc_hd__decap_3
XFILLER_61_258 VGND VGND VPWR VPWR sky130_fd_sc_hd__decap_3
XFILLER_61_269 VGND VGND VPWR VPWR sky130_fd_sc_hd__decap_3
XFILLER_14_152 VGND VGND VPWR VPWR sky130_fd_sc_hd__decap_3
XFILLER_30_623 VGND VGND VPWR VPWR sky130_fd_sc_hd__decap_3
XFILLER_42_472 VGND VGND VPWR VPWR sky130_fd_sc_hd__decap_3
XFILLER_30_645 VGND VGND VPWR VPWR sky130_fd_sc_hd__fill_2
XFILLER_42_483 VGND VGND VPWR VPWR sky130_fd_sc_hd__fill_2
XFILLER_115_205 VGND VGND VPWR VPWR sky130_fd_sc_hd__decap_3
Xhold808 _6738_/Q VGND VGND VPWR VPWR _6738_/D sky130_fd_sc_hd__dlygate4sd3_1
Xhold819 _6736_/Q VGND VGND VPWR VPWR _6736_/D sky130_fd_sc_hd__dlygate4sd3_1
XTAP_TAPCELL_ROW_12_397 VGND VPWR sky130_fd_sc_hd__tapvpwrvgnd_1
XTAP_TAPCELL_ROW_116_1639 VGND VPWR sky130_fd_sc_hd__tapvpwrvgnd_1
XFILLER_115_249 VGND VGND VPWR VPWR sky130_fd_sc_hd__decap_3
X_3460_ _7313_/Q _3989_/S _4338_/B1 _7345_/Q _4347_/C1 VGND VGND VPWR VPWR _3460_/X
+ sky130_fd_sc_hd__a221o_2
X_3391_ _7251_/Q _3358_/X _3390_/X VGND VGND VPWR VPWR _3589_/A sky130_fd_sc_hd__a21oi_2
XFILLER_97_612 VGND VGND VPWR VPWR sky130_fd_sc_hd__decap_3
XFILLER_97_623 VGND VGND VPWR VPWR sky130_fd_sc_hd__decap_3
X_5130_ _5130_/A _5670_/B _5130_/C VGND VGND VPWR VPWR _6982_/D sky130_fd_sc_hd__nor3_2
XFILLER_96_133 VGND VGND VPWR VPWR sky130_fd_sc_hd__decap_3
XFILLER_96_144 VGND VGND VPWR VPWR sky130_fd_sc_hd__decap_3
X_5061_ _6988_/D _5060_/X _5156_/S VGND VGND VPWR VPWR _5061_/X sky130_fd_sc_hd__mux2_2
XFILLER_97_656 VGND VGND VPWR VPWR sky130_fd_sc_hd__decap_3
XFILLER_84_328 VGND VGND VPWR VPWR sky130_fd_sc_hd__decap_3
XFILLER_37_266 VGND VGND VPWR VPWR sky130_fd_sc_hd__decap_3
XFILLER_80_501 VGND VGND VPWR VPWR sky130_fd_sc_hd__decap_3
XFILLER_52_214 VGND VGND VPWR VPWR sky130_fd_sc_hd__decap_3
XFILLER_65_597 VGND VGND VPWR VPWR sky130_fd_sc_hd__decap_3
XFILLER_92_383 VGND VGND VPWR VPWR sky130_fd_sc_hd__decap_3
XFILLER_80_556 VGND VGND VPWR VPWR sky130_fd_sc_hd__fill_1
X_4914_ _4914_/A0 _4913_/X _4946_/S VGND VGND VPWR VPWR _7267_/D sky130_fd_sc_hd__mux2_2
XFILLER_52_269 VGND VGND VPWR VPWR sky130_fd_sc_hd__decap_3
XFILLER_20_111 VGND VGND VPWR VPWR sky130_fd_sc_hd__decap_3
XFILLER_33_483 VGND VGND VPWR VPWR sky130_fd_sc_hd__decap_3
X_4845_ _4845_/A VGND VGND VPWR VPWR _4872_/A sky130_fd_sc_hd__inv_2
XFILLER_20_144 VGND VGND VPWR VPWR sky130_fd_sc_hd__decap_3
X_4776_ _7004_/Q _4804_/A VGND VGND VPWR VPWR _4777_/C sky130_fd_sc_hd__or2_2
X_6515_ _6611_/A VGND VGND VPWR VPWR _6515_/Y sky130_fd_sc_hd__inv_2
X_3727_ _3746_/B _3733_/C VGND VGND VPWR VPWR _3728_/B sky130_fd_sc_hd__nand2_2
XFILLER_106_9 VGND VGND VPWR VPWR sky130_fd_sc_hd__decap_3
X_6446_ _6606_/A VGND VGND VPWR VPWR _6446_/Y sky130_fd_sc_hd__inv_2
X_6377_ _6539_/A VGND VGND VPWR VPWR _6377_/Y sky130_fd_sc_hd__inv_2
X_3589_ _3589_/A _3589_/B VGND VGND VPWR VPWR _3590_/B sky130_fd_sc_hd__nor2_2
XFILLER_114_271 VGND VGND VPWR VPWR sky130_fd_sc_hd__decap_3
XFILLER_88_623 VGND VGND VPWR VPWR sky130_fd_sc_hd__decap_3
XFILLER_102_433 VGND VGND VPWR VPWR sky130_fd_sc_hd__decap_3
XFILLER_87_122 VGND VGND VPWR VPWR sky130_fd_sc_hd__decap_3
XFILLER_88_645 VGND VGND VPWR VPWR sky130_fd_sc_hd__decap_3
XFILLER_88_678 VGND VGND VPWR VPWR sky130_fd_sc_hd__decap_3
XFILLER_102_466 VGND VGND VPWR VPWR sky130_fd_sc_hd__decap_3
XFILLER_102_488 VGND VGND VPWR VPWR sky130_fd_sc_hd__fill_1
XFILLER_57_37 VGND VGND VPWR VPWR sky130_fd_sc_hd__decap_3
XFILLER_87_155 VGND VGND VPWR VPWR sky130_fd_sc_hd__decap_3
XFILLER_113_21 VGND VGND VPWR VPWR sky130_fd_sc_hd__decap_3
XFILLER_28_200 VGND VGND VPWR VPWR sky130_fd_sc_hd__decap_3
XFILLER_28_222 VGND VGND VPWR VPWR sky130_fd_sc_hd__decap_3
XFILLER_56_531 VGND VGND VPWR VPWR sky130_fd_sc_hd__fill_1
XFILLER_113_54 VGND VGND VPWR VPWR sky130_fd_sc_hd__fill_2
XFILLER_90_309 VGND VGND VPWR VPWR sky130_fd_sc_hd__fill_1
XFILLER_113_87 VGND VGND VPWR VPWR sky130_fd_sc_hd__decap_3
XFILLER_16_439 VGND VGND VPWR VPWR sky130_fd_sc_hd__fill_2
XFILLER_28_277 VGND VGND VPWR VPWR sky130_fd_sc_hd__decap_3
XFILLER_83_383 VGND VGND VPWR VPWR sky130_fd_sc_hd__decap_3
XFILLER_43_236 VGND VGND VPWR VPWR sky130_fd_sc_hd__fill_1
XFILLER_73_69 VGND VGND VPWR VPWR sky130_fd_sc_hd__decap_3
XFILLER_24_472 VGND VGND VPWR VPWR sky130_fd_sc_hd__decap_3
XFILLER_71_589 VGND VGND VPWR VPWR sky130_fd_sc_hd__decap_3
XFILLER_11_111 VGND VGND VPWR VPWR sky130_fd_sc_hd__fill_1
XFILLER_11_122 VGND VGND VPWR VPWR sky130_fd_sc_hd__decap_3
XFILLER_11_155 VGND VGND VPWR VPWR sky130_fd_sc_hd__decap_3
XFILLER_11_188 VGND VGND VPWR VPWR sky130_fd_sc_hd__decap_3
XFILLER_7_137 VGND VGND VPWR VPWR sky130_fd_sc_hd__decap_3
XFILLER_22_73 VGND VGND VPWR VPWR sky130_fd_sc_hd__fill_2
XFILLER_98_44 VGND VGND VPWR VPWR sky130_fd_sc_hd__decap_3
XFILLER_98_409 VGND VGND VPWR VPWR sky130_fd_sc_hd__decap_3
XFILLER_3_387 VGND VGND VPWR VPWR sky130_fd_sc_hd__decap_3
XFILLER_79_623 VGND VGND VPWR VPWR sky130_fd_sc_hd__decap_3
XFILLER_98_88 VGND VGND VPWR VPWR sky130_fd_sc_hd__decap_3
XFILLER_78_122 VGND VGND VPWR VPWR sky130_fd_sc_hd__fill_2
XFILLER_78_144 VGND VGND VPWR VPWR sky130_fd_sc_hd__fill_1
XFILLER_79_656 VGND VGND VPWR VPWR sky130_fd_sc_hd__decap_3
XFILLER_21_9 VGND VGND VPWR VPWR sky130_fd_sc_hd__decap_3
XFILLER_39_509 VGND VGND VPWR VPWR sky130_fd_sc_hd__decap_3
XFILLER_93_103 VGND VGND VPWR VPWR sky130_fd_sc_hd__fill_1
XFILLER_94_615 VGND VGND VPWR VPWR sky130_fd_sc_hd__decap_3
XFILLER_19_200 VGND VGND VPWR VPWR sky130_fd_sc_hd__decap_3
XFILLER_94_648 VGND VGND VPWR VPWR sky130_fd_sc_hd__decap_3
XFILLER_19_277 VGND VGND VPWR VPWR sky130_fd_sc_hd__decap_3
XFILLER_34_203 VGND VGND VPWR VPWR sky130_fd_sc_hd__decap_3
XFILLER_34_258 VGND VGND VPWR VPWR sky130_fd_sc_hd__decap_3
XFILLER_74_394 VGND VGND VPWR VPWR sky130_fd_sc_hd__decap_3
XTAP_TAPCELL_ROW_66_1048 VGND VPWR sky130_fd_sc_hd__tapvpwrvgnd_1
XFILLER_62_589 VGND VGND VPWR VPWR sky130_fd_sc_hd__decap_3
XTAP_TAPCELL_ROW_45_787 VGND VPWR sky130_fd_sc_hd__tapvpwrvgnd_1
XTAP_TAPCELL_ROW_17_456 VGND VPWR sky130_fd_sc_hd__tapvpwrvgnd_1
XFILLER_63_80 VGND VGND VPWR VPWR sky130_fd_sc_hd__decap_3
XFILLER_8_20 VGND VGND VPWR VPWR sky130_fd_sc_hd__decap_3
X_4630_ _4627_/Y _4629_/Y _4372_/A VGND VGND VPWR VPWR _4630_/X sky130_fd_sc_hd__a21o_2
XFILLER_30_497 VGND VGND VPWR VPWR sky130_fd_sc_hd__fill_2
XFILLER_8_53 VGND VGND VPWR VPWR sky130_fd_sc_hd__decap_3
XFILLER_7_660 VGND VGND VPWR VPWR sky130_fd_sc_hd__decap_3
XFILLER_8_97 VGND VGND VPWR VPWR sky130_fd_sc_hd__decap_3
X_6300_ _6366_/A VGND VGND VPWR VPWR _6300_/Y sky130_fd_sc_hd__inv_2
X_4561_ _4561_/A _4571_/B VGND VGND VPWR VPWR _7300_/D sky130_fd_sc_hd__and2_2
XFILLER_116_525 VGND VGND VPWR VPWR sky130_fd_sc_hd__decap_3
XFILLER_7_682 VGND VGND VPWR VPWR sky130_fd_sc_hd__decap_3
X_7280_ _7312_/CLK _7280_/D _6560_/Y VGND VGND VPWR VPWR _7280_/Q sky130_fd_sc_hd__dfrtp_2
Xhold605 _6799_/Q VGND VGND VPWR VPWR _6799_/D sky130_fd_sc_hd__dlygate4sd3_1
Xhold616 _6866_/Q VGND VGND VPWR VPWR _6866_/D sky130_fd_sc_hd__dlygate4sd3_1
Xhold627 _6895_/Q VGND VGND VPWR VPWR _6895_/D sky130_fd_sc_hd__dlygate4sd3_1
Xhold638 _6804_/Q VGND VGND VPWR VPWR _6804_/D sky130_fd_sc_hd__dlygate4sd3_1
Xhold649 _6975_/Q VGND VGND VPWR VPWR _6975_/D sky130_fd_sc_hd__dlygate4sd3_1
XTAP_TAPCELL_ROW_77_1177 VGND VPWR sky130_fd_sc_hd__tapvpwrvgnd_1
XTAP_TAPCELL_ROW_90_1333 VGND VPWR sky130_fd_sc_hd__tapvpwrvgnd_1
XFILLER_69_111 VGND VGND VPWR VPWR sky130_fd_sc_hd__fill_1
XFILLER_69_133 VGND VGND VPWR VPWR sky130_fd_sc_hd__decap_3
XFILLER_69_144 VGND VGND VPWR VPWR sky130_fd_sc_hd__decap_3
X_5113_ _5113_/A _5113_/B VGND VGND VPWR VPWR _5113_/Y sky130_fd_sc_hd__xnor2_2
XFILLER_85_626 VGND VGND VPWR VPWR sky130_fd_sc_hd__decap_3
XFILLER_97_464 VGND VGND VPWR VPWR sky130_fd_sc_hd__decap_3
XFILLER_111_296 VGND VGND VPWR VPWR sky130_fd_sc_hd__decap_3
XFILLER_27_18 VGND VGND VPWR VPWR sky130_fd_sc_hd__decap_3
XFILLER_57_328 VGND VGND VPWR VPWR sky130_fd_sc_hd__decap_3
XFILLER_69_199 VGND VGND VPWR VPWR sky130_fd_sc_hd__fill_1
XFILLER_84_114 VGND VGND VPWR VPWR sky130_fd_sc_hd__decap_3
XFILLER_85_659 VGND VGND VPWR VPWR sky130_fd_sc_hd__decap_3
X_5044_ _5044_/A _5044_/B VGND VGND VPWR VPWR _6988_/D sky130_fd_sc_hd__nor2_2
XFILLER_72_309 VGND VGND VPWR VPWR sky130_fd_sc_hd__decap_3
XFILLER_84_147 VGND VGND VPWR VPWR sky130_fd_sc_hd__decap_3
XFILLER_38_586 VGND VGND VPWR VPWR sky130_fd_sc_hd__fill_2
XFILLER_38_597 VGND VGND VPWR VPWR sky130_fd_sc_hd__fill_1
XFILLER_65_372 VGND VGND VPWR VPWR sky130_fd_sc_hd__decap_3
XFILLER_25_225 VGND VGND VPWR VPWR sky130_fd_sc_hd__fill_2
XFILLER_25_236 VGND VGND VPWR VPWR sky130_fd_sc_hd__fill_2
XFILLER_53_545 VGND VGND VPWR VPWR sky130_fd_sc_hd__decap_3
X_6995_ _7398_/CLK _6995_/D _6275_/Y VGND VGND VPWR VPWR _6995_/Q sky130_fd_sc_hd__dfrtp_2
XFILLER_40_217 VGND VGND VPWR VPWR sky130_fd_sc_hd__decap_3
XFILLER_53_589 VGND VGND VPWR VPWR sky130_fd_sc_hd__decap_3
X_4828_ _3526_/B _4810_/B _4827_/A _5033_/B2 VGND VGND VPWR VPWR _4828_/X sky130_fd_sc_hd__a22o_2
XFILLER_21_475 VGND VGND VPWR VPWR sky130_fd_sc_hd__fill_1
X_4759_ _4759_/A _4777_/B VGND VGND VPWR VPWR _4760_/B sky130_fd_sc_hd__xnor2_2
XFILLER_107_514 VGND VGND VPWR VPWR sky130_fd_sc_hd__decap_3
XFILLER_107_547 VGND VGND VPWR VPWR sky130_fd_sc_hd__decap_3
XFILLER_4_118 VGND VGND VPWR VPWR sky130_fd_sc_hd__decap_3
XFILLER_104_6 VGND VGND VPWR VPWR sky130_fd_sc_hd__decap_3
XFILLER_108_21 VGND VGND VPWR VPWR sky130_fd_sc_hd__decap_3
XFILLER_108_32 VGND VGND VPWR VPWR sky130_fd_sc_hd__decap_3
X_6429_ _6647_/A VGND VGND VPWR VPWR _6429_/Y sky130_fd_sc_hd__inv_2
XFILLER_108_65 VGND VGND VPWR VPWR sky130_fd_sc_hd__decap_3
XFILLER_68_14 VGND VGND VPWR VPWR sky130_fd_sc_hd__decap_3
XFILLER_0_324 VGND VGND VPWR VPWR sky130_fd_sc_hd__decap_3
XFILLER_115_591 VGND VGND VPWR VPWR sky130_fd_sc_hd__decap_3
XFILLER_68_58 VGND VGND VPWR VPWR sky130_fd_sc_hd__decap_3
XFILLER_88_442 VGND VGND VPWR VPWR sky130_fd_sc_hd__decap_3
XFILLER_0_368 VGND VGND VPWR VPWR sky130_fd_sc_hd__decap_3
XFILLER_76_604 VGND VGND VPWR VPWR sky130_fd_sc_hd__fill_1
XFILLER_102_274 VGND VGND VPWR VPWR sky130_fd_sc_hd__decap_3
XFILLER_76_648 VGND VGND VPWR VPWR sky130_fd_sc_hd__decap_3
XFILLER_29_553 VGND VGND VPWR VPWR sky130_fd_sc_hd__decap_3
XFILLER_29_564 VGND VGND VPWR VPWR sky130_fd_sc_hd__decap_3
XFILLER_75_169 VGND VGND VPWR VPWR sky130_fd_sc_hd__decap_3
XFILLER_84_35 VGND VGND VPWR VPWR sky130_fd_sc_hd__decap_3
XFILLER_16_203 VGND VGND VPWR VPWR sky130_fd_sc_hd__decap_3
XFILLER_56_361 VGND VGND VPWR VPWR sky130_fd_sc_hd__decap_3
XFILLER_84_681 VGND VGND VPWR VPWR sky130_fd_sc_hd__decap_3
XFILLER_84_79 VGND VGND VPWR VPWR sky130_fd_sc_hd__decap_3
XFILLER_90_106 VGND VGND VPWR VPWR sky130_fd_sc_hd__decap_3
XFILLER_91_629 VGND VGND VPWR VPWR sky130_fd_sc_hd__decap_3
Xplace309 _3522_/Y VGND VGND VPWR VPWR _5020_/A sky130_fd_sc_hd__buf_2
XFILLER_17_84 VGND VGND VPWR VPWR sky130_fd_sc_hd__decap_3
XFILLER_44_589 VGND VGND VPWR VPWR sky130_fd_sc_hd__decap_3
XFILLER_24_280 VGND VGND VPWR VPWR sky130_fd_sc_hd__decap_3
XFILLER_31_228 VGND VGND VPWR VPWR sky130_fd_sc_hd__decap_3
XTAP_TAPCELL_ROW_14_415 VGND VPWR sky130_fd_sc_hd__tapvpwrvgnd_1
XFILLER_12_464 VGND VGND VPWR VPWR sky130_fd_sc_hd__decap_3
XTAP_TAPCELL_ROW_42_757 VGND VPWR sky130_fd_sc_hd__tapvpwrvgnd_1
XFILLER_33_72 VGND VGND VPWR VPWR sky130_fd_sc_hd__decap_3
XFILLER_8_424 VGND VGND VPWR VPWR sky130_fd_sc_hd__decap_3
XFILLER_8_457 VGND VGND VPWR VPWR sky130_fd_sc_hd__fill_2
XFILLER_69_9 VGND VGND VPWR VPWR sky130_fd_sc_hd__decap_3
XFILLER_4_641 VGND VGND VPWR VPWR sky130_fd_sc_hd__decap_3
XTAP_TAPCELL_ROW_113_1609 VGND VPWR sky130_fd_sc_hd__tapvpwrvgnd_1
XFILLER_3_140 VGND VGND VPWR VPWR sky130_fd_sc_hd__decap_3
XFILLER_4_663 VGND VGND VPWR VPWR sky130_fd_sc_hd__decap_3
XFILLER_79_442 VGND VGND VPWR VPWR sky130_fd_sc_hd__decap_3
XFILLER_39_317 VGND VGND VPWR VPWR sky130_fd_sc_hd__decap_3
XFILLER_67_615 VGND VGND VPWR VPWR sky130_fd_sc_hd__fill_1
XFILLER_67_626 VGND VGND VPWR VPWR sky130_fd_sc_hd__decap_3
XFILLER_39_328 VGND VGND VPWR VPWR sky130_fd_sc_hd__fill_2
XFILLER_66_114 VGND VGND VPWR VPWR sky130_fd_sc_hd__decap_3
XFILLER_67_659 VGND VGND VPWR VPWR sky130_fd_sc_hd__decap_3
XFILLER_66_147 VGND VGND VPWR VPWR sky130_fd_sc_hd__decap_3
XFILLER_82_607 VGND VGND VPWR VPWR sky130_fd_sc_hd__decap_3
XFILLER_47_383 VGND VGND VPWR VPWR sky130_fd_sc_hd__decap_3
XFILLER_81_128 VGND VGND VPWR VPWR sky130_fd_sc_hd__decap_3
XFILLER_62_331 VGND VGND VPWR VPWR sky130_fd_sc_hd__fill_2
XFILLER_90_640 VGND VGND VPWR VPWR sky130_fd_sc_hd__decap_3
XFILLER_90_651 VGND VGND VPWR VPWR sky130_fd_sc_hd__decap_3
XFILLER_22_206 VGND VGND VPWR VPWR sky130_fd_sc_hd__fill_1
XFILLER_62_353 VGND VGND VPWR VPWR sky130_fd_sc_hd__fill_1
XFILLER_90_684 VGND VGND VPWR VPWR sky130_fd_sc_hd__decap_3
X_6780_ _7386_/CLK _6780_/D VGND VGND VPWR VPWR _6780_/Q sky130_fd_sc_hd__dfxtp_2
X_3992_ _5156_/S _5587_/B VGND VGND VPWR VPWR _3992_/Y sky130_fd_sc_hd__nand2_2
XFILLER_22_217 VGND VGND VPWR VPWR sky130_fd_sc_hd__decap_3
XFILLER_50_559 VGND VGND VPWR VPWR sky130_fd_sc_hd__decap_3
X_5731_ _7371_/Q hold915/X _5737_/S VGND VGND VPWR VPWR _6715_/D sky130_fd_sc_hd__mux2_2
X_5662_ _5662_/A _5662_/B _5662_/C _5661_/X VGND VGND VPWR VPWR _5663_/D sky130_fd_sc_hd__or4b_4
X_7401_ _7403_/CLK _7401_/D _6681_/Y VGND VGND VPWR VPWR _7401_/Q sky130_fd_sc_hd__dfrtp_2
X_5593_ _5593_/A _5595_/B VGND VGND VPWR VPWR _7031_/D sky130_fd_sc_hd__or2_2
X_4613_ _4614_/B _4613_/B _5113_/A VGND VGND VPWR VPWR _4617_/B sky130_fd_sc_hd__and3_2
X_7332_ _7364_/CLK _7332_/D _6612_/Y VGND VGND VPWR VPWR _7332_/Q sky130_fd_sc_hd__dfrtp_2
X_4544_ _4544_/A _4571_/B VGND VGND VPWR VPWR _7308_/D sky130_fd_sc_hd__and2_2
XFILLER_116_333 VGND VGND VPWR VPWR sky130_fd_sc_hd__decap_3
X_7263_ _7266_/CLK _7263_/D _6543_/Y VGND VGND VPWR VPWR _7263_/Q sky130_fd_sc_hd__dfrtp_2
XFILLER_104_506 VGND VGND VPWR VPWR sky130_fd_sc_hd__decap_3
XFILLER_116_388 VGND VGND VPWR VPWR sky130_fd_sc_hd__decap_3
XFILLER_89_217 VGND VGND VPWR VPWR sky130_fd_sc_hd__decap_3
XFILLER_89_228 VGND VGND VPWR VPWR sky130_fd_sc_hd__decap_3
XFILLER_116_399 VGND VGND VPWR VPWR sky130_fd_sc_hd__decap_3
X_7194_ _7360_/CLK _7194_/D _6474_/Y VGND VGND VPWR VPWR _7194_/Q sky130_fd_sc_hd__dfrtp_2
X_3426_ _3589_/A _3591_/A _3589_/B _3590_/C VGND VGND VPWR VPWR _3427_/B sky130_fd_sc_hd__or4_4
XFILLER_58_604 VGND VGND VPWR VPWR sky130_fd_sc_hd__decap_3
XFILLER_85_401 VGND VGND VPWR VPWR sky130_fd_sc_hd__decap_3
X_3357_ _4537_/B VGND VGND VPWR VPWR _3449_/A sky130_fd_sc_hd__inv_6
XFILLER_112_572 VGND VGND VPWR VPWR sky130_fd_sc_hd__decap_3
XFILLER_38_39 VGND VGND VPWR VPWR sky130_fd_sc_hd__decap_3
XFILLER_57_103 VGND VGND VPWR VPWR sky130_fd_sc_hd__decap_3
XFILLER_58_637 VGND VGND VPWR VPWR sky130_fd_sc_hd__decap_3
XFILLER_58_648 VGND VGND VPWR VPWR sky130_fd_sc_hd__decap_3
XFILLER_97_272 VGND VGND VPWR VPWR sky130_fd_sc_hd__decap_3
Xhold1102 _7282_/Q VGND VGND VPWR VPWR _4597_/A0 sky130_fd_sc_hd__dlygate4sd3_1
Xhold1113 _7299_/Q VGND VGND VPWR VPWR _4563_/A sky130_fd_sc_hd__dlygate4sd3_1
Xhold1124 _4505_/X VGND VGND VPWR VPWR _7327_/D sky130_fd_sc_hd__dlygate4sd3_1
XFILLER_57_147 VGND VGND VPWR VPWR sky130_fd_sc_hd__decap_3
XFILLER_57_169 VGND VGND VPWR VPWR sky130_fd_sc_hd__decap_3
Xhold1135 _7136_/Q VGND VGND VPWR VPWR _5394_/A0 sky130_fd_sc_hd__dlygate4sd3_1
Xhold1146 _7138_/Q VGND VGND VPWR VPWR _5390_/A0 sky130_fd_sc_hd__dlygate4sd3_1
Xhold1157 _7149_/Q VGND VGND VPWR VPWR _5367_/A0 sky130_fd_sc_hd__dlygate4sd3_1
X_5027_ _5092_/C _5024_/X _6990_/D _5666_/A VGND VGND VPWR VPWR _5027_/X sky130_fd_sc_hd__a22o_2
XFILLER_26_501 VGND VGND VPWR VPWR sky130_fd_sc_hd__fill_2
XFILLER_26_523 VGND VGND VPWR VPWR sky130_fd_sc_hd__fill_1
XFILLER_66_681 VGND VGND VPWR VPWR sky130_fd_sc_hd__decap_3
XFILLER_73_629 VGND VGND VPWR VPWR sky130_fd_sc_hd__decap_3
Xhold1168 _7140_/Q VGND VGND VPWR VPWR _5386_/A0 sky130_fd_sc_hd__dlygate4sd3_1
Xhold1179 _7133_/Q VGND VGND VPWR VPWR _5400_/A0 sky130_fd_sc_hd__dlygate4sd3_1
XFILLER_26_556 VGND VGND VPWR VPWR sky130_fd_sc_hd__fill_1
XFILLER_38_394 VGND VGND VPWR VPWR sky130_fd_sc_hd__decap_3
XFILLER_54_27 VGND VGND VPWR VPWR sky130_fd_sc_hd__fill_1
XFILLER_26_589 VGND VGND VPWR VPWR sky130_fd_sc_hd__decap_3
XFILLER_80_150 VGND VGND VPWR VPWR sky130_fd_sc_hd__fill_2
XFILLER_81_662 VGND VGND VPWR VPWR sky130_fd_sc_hd__decap_3
XFILLER_81_673 VGND VGND VPWR VPWR sky130_fd_sc_hd__decap_3
XFILLER_110_44 VGND VGND VPWR VPWR sky130_fd_sc_hd__decap_3
XFILLER_13_228 VGND VGND VPWR VPWR sky130_fd_sc_hd__decap_3
XFILLER_41_548 VGND VGND VPWR VPWR sky130_fd_sc_hd__decap_3
XFILLER_80_172 VGND VGND VPWR VPWR sky130_fd_sc_hd__decap_3
X_6978_ _6978_/CLK _6978_/D VGND VGND VPWR VPWR _6978_/Q sky130_fd_sc_hd__dfxtp_2
XFILLER_110_77 VGND VGND VPWR VPWR sky130_fd_sc_hd__decap_3
XFILLER_70_15 VGND VGND VPWR VPWR sky130_fd_sc_hd__decap_3
XFILLER_110_88 VGND VGND VPWR VPWR sky130_fd_sc_hd__decap_3
XFILLER_21_272 VGND VGND VPWR VPWR sky130_fd_sc_hd__decap_3
XFILLER_70_37 VGND VGND VPWR VPWR sky130_fd_sc_hd__decap_3
XFILLER_5_405 VGND VGND VPWR VPWR sky130_fd_sc_hd__decap_3
XFILLER_5_438 VGND VGND VPWR VPWR sky130_fd_sc_hd__decap_3
XFILLER_107_333 VGND VGND VPWR VPWR sky130_fd_sc_hd__decap_3
XFILLER_5_449 VGND VGND VPWR VPWR sky130_fd_sc_hd__decap_3
XFILLER_102_3 VGND VGND VPWR VPWR sky130_fd_sc_hd__decap_3
XFILLER_1_600 VGND VGND VPWR VPWR sky130_fd_sc_hd__decap_3
XFILLER_79_57 VGND VGND VPWR VPWR sky130_fd_sc_hd__decap_3
XFILLER_0_110 VGND VGND VPWR VPWR sky130_fd_sc_hd__fill_2
Xhold991 _7377_/Q VGND VGND VPWR VPWR hold991/X sky130_fd_sc_hd__dlygate4sd3_1
Xhold980 _7052_/Q VGND VGND VPWR VPWR hold980/X sky130_fd_sc_hd__dlygate4sd3_1
XFILLER_0_132 VGND VGND VPWR VPWR sky130_fd_sc_hd__decap_3
XFILLER_103_561 VGND VGND VPWR VPWR sky130_fd_sc_hd__decap_3
XFILLER_1_655 VGND VGND VPWR VPWR sky130_fd_sc_hd__decap_3
XFILLER_49_615 VGND VGND VPWR VPWR sky130_fd_sc_hd__fill_1
XFILLER_95_12 VGND VGND VPWR VPWR sky130_fd_sc_hd__decap_3
XFILLER_48_114 VGND VGND VPWR VPWR sky130_fd_sc_hd__decap_3
XFILLER_49_626 VGND VGND VPWR VPWR sky130_fd_sc_hd__decap_3
XFILLER_36_309 VGND VGND VPWR VPWR sky130_fd_sc_hd__decap_3
XFILLER_49_659 VGND VGND VPWR VPWR sky130_fd_sc_hd__decap_3
XFILLER_64_607 VGND VGND VPWR VPWR sky130_fd_sc_hd__decap_3
XFILLER_76_445 VGND VGND VPWR VPWR sky130_fd_sc_hd__decap_3
XFILLER_95_89 VGND VGND VPWR VPWR sky130_fd_sc_hd__decap_3
XFILLER_28_61 VGND VGND VPWR VPWR sky130_fd_sc_hd__decap_3
XFILLER_48_169 VGND VGND VPWR VPWR sky130_fd_sc_hd__decap_3
XFILLER_63_128 VGND VGND VPWR VPWR sky130_fd_sc_hd__decap_3
XFILLER_91_415 VGND VGND VPWR VPWR sky130_fd_sc_hd__decap_3
XTAP_TAPCELL_ROW_47_816 VGND VPWR sky130_fd_sc_hd__tapvpwrvgnd_1
XFILLER_44_320 VGND VGND VPWR VPWR sky130_fd_sc_hd__decap_3
XFILLER_56_180 VGND VGND VPWR VPWR sky130_fd_sc_hd__decap_3
XFILLER_56_191 VGND VGND VPWR VPWR sky130_fd_sc_hd__decap_3
XFILLER_17_567 VGND VGND VPWR VPWR sky130_fd_sc_hd__decap_3
XFILLER_32_504 VGND VGND VPWR VPWR sky130_fd_sc_hd__decap_3
XFILLER_32_515 VGND VGND VPWR VPWR sky130_fd_sc_hd__decap_3
XFILLER_71_150 VGND VGND VPWR VPWR sky130_fd_sc_hd__decap_3
XFILLER_72_651 VGND VGND VPWR VPWR sky130_fd_sc_hd__decap_3
XFILLER_72_684 VGND VGND VPWR VPWR sky130_fd_sc_hd__decap_3
XTAP_TAPCELL_ROW_63_1007 VGND VPWR sky130_fd_sc_hd__tapvpwrvgnd_1
XFILLER_71_172 VGND VGND VPWR VPWR sky130_fd_sc_hd__decap_3
XTAP_TAPCELL_ROW_27_573 VGND VPWR sky130_fd_sc_hd__tapvpwrvgnd_1
XFILLER_32_559 VGND VGND VPWR VPWR sky130_fd_sc_hd__decap_3
XFILLER_12_283 VGND VGND VPWR VPWR sky130_fd_sc_hd__decap_3
XFILLER_60_81 VGND VGND VPWR VPWR sky130_fd_sc_hd__decap_3
XFILLER_67_6 VGND VGND VPWR VPWR sky130_fd_sc_hd__decap_3
XFILLER_5_21 VGND VGND VPWR VPWR sky130_fd_sc_hd__decap_3
Xoutput518 _3339_/C1 VGND VGND VPWR VPWR instruction_out[6] sky130_fd_sc_hd__clkdlybuf4s25_1
Xoutput507 _3449_/C VGND VGND VPWR VPWR instruction_out[23] sky130_fd_sc_hd__clkdlybuf4s25_1
XFILLER_5_54 VGND VGND VPWR VPWR sky130_fd_sc_hd__fill_2
Xoutput529 _6993_/Q VGND VGND VPWR VPWR pc_out[16] sky130_fd_sc_hd__clkdlybuf4s25_1
XTAP_TAPCELL_ROW_74_1136 VGND VPWR sky130_fd_sc_hd__tapvpwrvgnd_1
XFILLER_5_87 VGND VGND VPWR VPWR sky130_fd_sc_hd__decap_3
X_4260_ _7262_/Q _4356_/A2 _3964_/S _7326_/Q VGND VGND VPWR VPWR _4264_/A sky130_fd_sc_hd__a22o_2
XFILLER_69_90 VGND VGND VPWR VPWR sky130_fd_sc_hd__decap_3
XFILLER_86_209 VGND VGND VPWR VPWR sky130_fd_sc_hd__decap_3
X_4191_ _7071_/Q _4265_/B _4205_/A VGND VGND VPWR VPWR _4637_/C sky130_fd_sc_hd__o21a_2
XFILLER_67_412 VGND VGND VPWR VPWR sky130_fd_sc_hd__fill_1
XFILLER_94_220 VGND VGND VPWR VPWR sky130_fd_sc_hd__decap_3
XFILLER_94_253 VGND VGND VPWR VPWR sky130_fd_sc_hd__fill_1
XFILLER_39_169 VGND VGND VPWR VPWR sky130_fd_sc_hd__decap_3
XFILLER_48_681 VGND VGND VPWR VPWR sky130_fd_sc_hd__decap_3
XFILLER_54_106 VGND VGND VPWR VPWR sky130_fd_sc_hd__decap_3
XFILLER_55_629 VGND VGND VPWR VPWR sky130_fd_sc_hd__decap_3
X_6901_ _6909_/CLK _6901_/D VGND VGND VPWR VPWR _6901_/Q sky130_fd_sc_hd__dfxtp_2
XFILLER_35_364 VGND VGND VPWR VPWR sky130_fd_sc_hd__decap_3
XFILLER_62_150 VGND VGND VPWR VPWR sky130_fd_sc_hd__decap_3
XFILLER_63_662 VGND VGND VPWR VPWR sky130_fd_sc_hd__decap_3
XFILLER_63_673 VGND VGND VPWR VPWR sky130_fd_sc_hd__decap_3
X_6832_ _6972_/CLK _6832_/D VGND VGND VPWR VPWR _6832_/Q sky130_fd_sc_hd__dfxtp_2
XFILLER_50_323 VGND VGND VPWR VPWR sky130_fd_sc_hd__decap_3
XFILLER_62_172 VGND VGND VPWR VPWR sky130_fd_sc_hd__decap_3
XTAP_TAPCELL_ROW_85_1276 VGND VPWR sky130_fd_sc_hd__tapvpwrvgnd_1
XFILLER_23_559 VGND VGND VPWR VPWR sky130_fd_sc_hd__fill_1
X_6763_ _6971_/CLK _6763_/D VGND VGND VPWR VPWR _6763_/Q sky130_fd_sc_hd__dfxtp_2
X_3975_ _7353_/Q _4517_/A0 _4471_/S VGND VGND VPWR VPWR _7353_/D sky130_fd_sc_hd__mux2_2
XFILLER_10_209 VGND VGND VPWR VPWR sky130_fd_sc_hd__decap_3
X_6694_ _7384_/CLK _6694_/D VGND VGND VPWR VPWR _6694_/Q sky130_fd_sc_hd__dfxtp_2
XFILLER_109_609 VGND VGND VPWR VPWR sky130_fd_sc_hd__decap_3
XFILLER_40_18 VGND VGND VPWR VPWR sky130_fd_sc_hd__decap_3
X_5645_ _5129_/A _6979_/Q _3519_/B _5644_/X VGND VGND VPWR VPWR _5645_/X sky130_fd_sc_hd__o31a_2
X_5576_ hold943/X _5598_/A2 _5015_/X VGND VGND VPWR VPWR _7041_/D sky130_fd_sc_hd__a21o_2
XFILLER_116_141 VGND VGND VPWR VPWR sky130_fd_sc_hd__decap_3
XFILLER_2_419 VGND VGND VPWR VPWR sky130_fd_sc_hd__fill_1
X_7315_ _7384_/CLK _7315_/D _6595_/Y VGND VGND VPWR VPWR _7315_/Q sky130_fd_sc_hd__dfrtp_2
XFILLER_104_336 VGND VGND VPWR VPWR sky130_fd_sc_hd__decap_3
XFILLER_49_27 VGND VGND VPWR VPWR sky130_fd_sc_hd__fill_1
X_7246_ _7372_/CLK _7246_/D _6526_/Y VGND VGND VPWR VPWR _7246_/Q sky130_fd_sc_hd__dfrtp_2
X_4458_ _4458_/A _4039_/A VGND VGND VPWR VPWR _4458_/X sky130_fd_sc_hd__or2b_2
XFILLER_104_358 VGND VGND VPWR VPWR sky130_fd_sc_hd__decap_3
X_7177_ _7402_/CLK _7177_/D _6457_/Y VGND VGND VPWR VPWR _7177_/Q sky130_fd_sc_hd__dfrtp_2
X_3409_ _3449_/A _3449_/B _3421_/C _3409_/D VGND VGND VPWR VPWR _3409_/X sky130_fd_sc_hd__and4_2
XFILLER_105_33 VGND VGND VPWR VPWR sky130_fd_sc_hd__decap_3
X_4389_ _7081_/Q _4432_/A2 _4432_/B1 _4388_/X VGND VGND VPWR VPWR _4396_/A sky130_fd_sc_hd__o211ai_2
XFILLER_100_542 VGND VGND VPWR VPWR sky130_fd_sc_hd__decap_3
XFILLER_112_391 VGND VGND VPWR VPWR sky130_fd_sc_hd__decap_3
XFILLER_65_15 VGND VGND VPWR VPWR sky130_fd_sc_hd__decap_3
XFILLER_85_231 VGND VGND VPWR VPWR sky130_fd_sc_hd__decap_3
XFILLER_46_629 VGND VGND VPWR VPWR sky130_fd_sc_hd__decap_3
XFILLER_85_286 VGND VGND VPWR VPWR sky130_fd_sc_hd__fill_2
XFILLER_100_597 VGND VGND VPWR VPWR sky130_fd_sc_hd__fill_2
XFILLER_26_331 VGND VGND VPWR VPWR sky130_fd_sc_hd__decap_3
XFILLER_38_191 VGND VGND VPWR VPWR sky130_fd_sc_hd__decap_3
XFILLER_54_640 VGND VGND VPWR VPWR sky130_fd_sc_hd__decap_3
XFILLER_73_459 VGND VGND VPWR VPWR sky130_fd_sc_hd__decap_3
XFILLER_14_504 VGND VGND VPWR VPWR sky130_fd_sc_hd__decap_3
XFILLER_54_651 VGND VGND VPWR VPWR sky130_fd_sc_hd__decap_3
XFILLER_26_397 VGND VGND VPWR VPWR sky130_fd_sc_hd__decap_3
XFILLER_41_301 VGND VGND VPWR VPWR sky130_fd_sc_hd__decap_3
XFILLER_53_172 VGND VGND VPWR VPWR sky130_fd_sc_hd__decap_3
XFILLER_54_684 VGND VGND VPWR VPWR sky130_fd_sc_hd__decap_3
XFILLER_81_36 VGND VGND VPWR VPWR sky130_fd_sc_hd__decap_3
XTAP_TAPCELL_ROW_24_543 VGND VPWR sky130_fd_sc_hd__tapvpwrvgnd_1
XFILLER_14_41 VGND VGND VPWR VPWR sky130_fd_sc_hd__decap_3
XFILLER_41_378 VGND VGND VPWR VPWR sky130_fd_sc_hd__decap_3
XFILLER_41_389 VGND VGND VPWR VPWR sky130_fd_sc_hd__decap_3
XTAP_TAPCELL_ROW_52_874 VGND VPWR sky130_fd_sc_hd__tapvpwrvgnd_1
XFILLER_14_74 VGND VGND VPWR VPWR sky130_fd_sc_hd__decap_3
XFILLER_108_631 VGND VGND VPWR VPWR sky130_fd_sc_hd__decap_3
XFILLER_5_246 VGND VGND VPWR VPWR sky130_fd_sc_hd__decap_3
XFILLER_108_675 VGND VGND VPWR VPWR sky130_fd_sc_hd__decap_3
XFILLER_30_62 VGND VGND VPWR VPWR sky130_fd_sc_hd__decap_3
XFILLER_5_268 VGND VGND VPWR VPWR sky130_fd_sc_hd__decap_3
XFILLER_107_196 VGND VGND VPWR VPWR sky130_fd_sc_hd__decap_3
XFILLER_1_441 VGND VGND VPWR VPWR sky130_fd_sc_hd__decap_3
XFILLER_1_452 VGND VGND VPWR VPWR sky130_fd_sc_hd__decap_3
XFILLER_68_209 VGND VGND VPWR VPWR sky130_fd_sc_hd__fill_2
XFILLER_103_391 VGND VGND VPWR VPWR sky130_fd_sc_hd__fill_1
XFILLER_39_71 VGND VGND VPWR VPWR sky130_fd_sc_hd__fill_2
XFILLER_39_82 VGND VGND VPWR VPWR sky130_fd_sc_hd__decap_3
XFILLER_49_434 VGND VGND VPWR VPWR sky130_fd_sc_hd__decap_3
XFILLER_76_231 VGND VGND VPWR VPWR sky130_fd_sc_hd__decap_3
XFILLER_17_320 VGND VGND VPWR VPWR sky130_fd_sc_hd__decap_3
XFILLER_36_128 VGND VGND VPWR VPWR sky130_fd_sc_hd__decap_3
XFILLER_91_223 VGND VGND VPWR VPWR sky130_fd_sc_hd__fill_1
XFILLER_91_245 VGND VGND VPWR VPWR sky130_fd_sc_hd__decap_3
XFILLER_45_673 VGND VGND VPWR VPWR sky130_fd_sc_hd__decap_3
XFILLER_55_81 VGND VGND VPWR VPWR sky130_fd_sc_hd__decap_3
XFILLER_91_256 VGND VGND VPWR VPWR sky130_fd_sc_hd__decap_3
XFILLER_32_312 VGND VGND VPWR VPWR sky130_fd_sc_hd__decap_3
XFILLER_44_183 VGND VGND VPWR VPWR sky130_fd_sc_hd__decap_3
XFILLER_60_610 VGND VGND VPWR VPWR sky130_fd_sc_hd__decap_3
XFILLER_91_289 VGND VGND VPWR VPWR sky130_fd_sc_hd__decap_3
XFILLER_60_643 VGND VGND VPWR VPWR sky130_fd_sc_hd__fill_1
XFILLER_60_654 VGND VGND VPWR VPWR sky130_fd_sc_hd__decap_3
XFILLER_60_687 VGND VGND VPWR VPWR sky130_fd_sc_hd__decap_3
X_3760_ _6933_/Q _3768_/A2 _3767_/A2 _6707_/Q VGND VGND VPWR VPWR _3760_/X sky130_fd_sc_hd__a22o_2
XFILLER_71_91 VGND VGND VPWR VPWR sky130_fd_sc_hd__fill_2
X_3691_ _6941_/Q _3768_/A2 _3759_/A2 _6805_/Q VGND VGND VPWR VPWR _3691_/X sky130_fd_sc_hd__a22o_2
XFILLER_65_3 VGND VGND VPWR VPWR sky130_fd_sc_hd__decap_3
XFILLER_114_601 VGND VGND VPWR VPWR sky130_fd_sc_hd__decap_3
XFILLER_113_111 VGND VGND VPWR VPWR sky130_fd_sc_hd__fill_1
XFILLER_113_122 VGND VGND VPWR VPWR sky130_fd_sc_hd__decap_3
XFILLER_114_634 VGND VGND VPWR VPWR sky130_fd_sc_hd__decap_3
XFILLER_114_645 VGND VGND VPWR VPWR sky130_fd_sc_hd__decap_3
X_7100_ clkload7/A _7100_/D _6380_/Y VGND VGND VPWR VPWR _7100_/Q sky130_fd_sc_hd__dfrtp_2
X_5292_ _5292_/A0 _4470_/X _5292_/S VGND VGND VPWR VPWR _7183_/D sky130_fd_sc_hd__mux2_2
X_4312_ _4394_/A _4337_/B _4311_/X VGND VGND VPWR VPWR _4313_/D sky130_fd_sc_hd__or3b_2
XFILLER_99_345 VGND VGND VPWR VPWR sky130_fd_sc_hd__fill_2
XFILLER_99_334 VGND VGND VPWR VPWR sky130_fd_sc_hd__fill_2
XFILLER_113_155 VGND VGND VPWR VPWR sky130_fd_sc_hd__decap_3
XFILLER_114_678 VGND VGND VPWR VPWR sky130_fd_sc_hd__decap_3
X_7031_ clkload9/A _7031_/D _6311_/Y VGND VGND VPWR VPWR _7031_/Q sky130_fd_sc_hd__dfrtp_2
X_4243_ _4620_/A _5032_/A VGND VGND VPWR VPWR _4243_/Y sky130_fd_sc_hd__nor2_2
XFILLER_99_378 VGND VGND VPWR VPWR sky130_fd_sc_hd__decap_3
XFILLER_101_328 VGND VGND VPWR VPWR sky130_fd_sc_hd__decap_3
XFILLER_113_199 VGND VGND VPWR VPWR sky130_fd_sc_hd__decap_3
XFILLER_67_220 VGND VGND VPWR VPWR sky130_fd_sc_hd__decap_3
XFILLER_67_231 VGND VGND VPWR VPWR sky130_fd_sc_hd__decap_3
XFILLER_95_540 VGND VGND VPWR VPWR sky130_fd_sc_hd__decap_3
X_4174_ _7296_/Q _4503_/S _4261_/A2 _7360_/Q VGND VGND VPWR VPWR _4174_/X sky130_fd_sc_hd__a22o_2
XFILLER_55_415 VGND VGND VPWR VPWR sky130_fd_sc_hd__decap_3
XFILLER_27_128 VGND VGND VPWR VPWR sky130_fd_sc_hd__decap_3
XFILLER_82_212 VGND VGND VPWR VPWR sky130_fd_sc_hd__decap_3
XFILLER_70_418 VGND VGND VPWR VPWR sky130_fd_sc_hd__fill_2
XFILLER_82_245 VGND VGND VPWR VPWR sky130_fd_sc_hd__decap_3
XFILLER_82_256 VGND VGND VPWR VPWR sky130_fd_sc_hd__decap_3
XFILLER_23_301 VGND VGND VPWR VPWR sky130_fd_sc_hd__decap_3
XFILLER_23_312 VGND VGND VPWR VPWR sky130_fd_sc_hd__decap_3
XFILLER_51_632 VGND VGND VPWR VPWR sky130_fd_sc_hd__decap_3
XFILLER_63_470 VGND VGND VPWR VPWR sky130_fd_sc_hd__decap_3
XFILLER_23_356 VGND VGND VPWR VPWR sky130_fd_sc_hd__decap_3
XFILLER_50_120 VGND VGND VPWR VPWR sky130_fd_sc_hd__decap_3
XFILLER_51_665 VGND VGND VPWR VPWR sky130_fd_sc_hd__decap_3
X_6815_ clkload2/A _6815_/D VGND VGND VPWR VPWR _6815_/Q sky130_fd_sc_hd__dfxtp_2
XFILLER_50_164 VGND VGND VPWR VPWR sky130_fd_sc_hd__decap_3
XFILLER_51_676 VGND VGND VPWR VPWR sky130_fd_sc_hd__decap_3
X_6746_ _6976_/CLK _6746_/D VGND VGND VPWR VPWR _6746_/Q sky130_fd_sc_hd__dfxtp_2
XTAP_TAPCELL_ROW_21_502 VGND VPWR sky130_fd_sc_hd__tapvpwrvgnd_1
XFILLER_50_197 VGND VGND VPWR VPWR sky130_fd_sc_hd__decap_3
XFILLER_51_39 VGND VGND VPWR VPWR sky130_fd_sc_hd__decap_3
X_3958_ _7361_/Q _4501_/A0 _3958_/S VGND VGND VPWR VPWR _7361_/D sky130_fd_sc_hd__mux2_2
XFILLER_109_417 VGND VGND VPWR VPWR sky130_fd_sc_hd__decap_3
X_6677_ _6684_/A VGND VGND VPWR VPWR _6677_/Y sky130_fd_sc_hd__inv_2
X_3889_ _6834_/Q _3889_/A2 _3889_/B1 _6829_/Q _3888_/X VGND VGND VPWR VPWR _3889_/X
+ sky130_fd_sc_hd__a221o_2
XTAP_TAPCELL_ROW_98_1423 VGND VPWR sky130_fd_sc_hd__tapvpwrvgnd_1
X_5628_ _5628_/A _5633_/B VGND VGND VPWR VPWR _7014_/D sky130_fd_sc_hd__or2_2
XFILLER_105_601 VGND VGND VPWR VPWR sky130_fd_sc_hd__decap_3
XFILLER_104_100 VGND VGND VPWR VPWR sky130_fd_sc_hd__decap_3
XFILLER_104_122 VGND VGND VPWR VPWR sky130_fd_sc_hd__decap_3
XFILLER_105_623 VGND VGND VPWR VPWR sky130_fd_sc_hd__decap_3
XFILLER_104_144 VGND VGND VPWR VPWR sky130_fd_sc_hd__decap_3
XFILLER_105_656 VGND VGND VPWR VPWR sky130_fd_sc_hd__decap_3
XFILLER_116_32 VGND VGND VPWR VPWR sky130_fd_sc_hd__decap_3
XFILLER_104_166 VGND VGND VPWR VPWR sky130_fd_sc_hd__decap_3
XFILLER_116_65 VGND VGND VPWR VPWR sky130_fd_sc_hd__decap_3
X_7229_ _7294_/CLK _7229_/D _6509_/Y VGND VGND VPWR VPWR _7229_/Q sky130_fd_sc_hd__dfrtp_2
XFILLER_100_361 VGND VGND VPWR VPWR sky130_fd_sc_hd__decap_3
XFILLER_46_415 VGND VGND VPWR VPWR sky130_fd_sc_hd__decap_3
XFILLER_58_264 VGND VGND VPWR VPWR sky130_fd_sc_hd__fill_2
XTAP_TAPCELL_ROW_29_602 VGND VPWR sky130_fd_sc_hd__tapvpwrvgnd_1
XFILLER_100_383 VGND VGND VPWR VPWR sky130_fd_sc_hd__decap_3
XTAP_TAPCELL_ROW_57_933 VGND VPWR sky130_fd_sc_hd__tapvpwrvgnd_1
XFILLER_73_245 VGND VGND VPWR VPWR sky130_fd_sc_hd__decap_3
XTAP_TAPCELL_ROW_1_260 VGND VPWR sky130_fd_sc_hd__tapvpwrvgnd_1
XTAP_TAPCELL_ROW_107_1541 VGND VPWR sky130_fd_sc_hd__tapvpwrvgnd_1
XTAP_TAPCELL_ROW_107_1530 VGND VPWR sky130_fd_sc_hd__tapvpwrvgnd_1
XFILLER_26_172 VGND VGND VPWR VPWR sky130_fd_sc_hd__fill_1
XFILLER_27_673 VGND VGND VPWR VPWR sky130_fd_sc_hd__fill_2
XFILLER_42_621 VGND VGND VPWR VPWR sky130_fd_sc_hd__decap_3
XFILLER_92_57 VGND VGND VPWR VPWR sky130_fd_sc_hd__decap_3
XFILLER_26_194 VGND VGND VPWR VPWR sky130_fd_sc_hd__fill_2
XFILLER_41_131 VGND VGND VPWR VPWR sky130_fd_sc_hd__decap_3
XFILLER_42_665 VGND VGND VPWR VPWR sky130_fd_sc_hd__decap_3
XTAP_TAPCELL_ROW_37_690 VGND VPWR sky130_fd_sc_hd__tapvpwrvgnd_1
XPHY_EDGE_ROW_1_Left_118 VGND VGND VPWR VPWR sky130_fd_sc_hd__decap_3
XFILLER_41_186 VGND VGND VPWR VPWR sky130_fd_sc_hd__decap_3
XFILLER_41_50 VGND VGND VPWR VPWR sky130_fd_sc_hd__decap_3
XFILLER_41_72 VGND VGND VPWR VPWR sky130_fd_sc_hd__decap_3
XFILLER_6_533 VGND VGND VPWR VPWR sky130_fd_sc_hd__fill_1
XFILLER_51_9 VGND VGND VPWR VPWR sky130_fd_sc_hd__decap_3
XTAP_TAPCELL_ROW_9_360 VGND VPWR sky130_fd_sc_hd__tapvpwrvgnd_1
XTAP_TAPCELL_ROW_71_1106 VGND VPWR sky130_fd_sc_hd__tapvpwrvgnd_1
XFILLER_110_103 VGND VGND VPWR VPWR sky130_fd_sc_hd__decap_3
XFILLER_111_615 VGND VGND VPWR VPWR sky130_fd_sc_hd__fill_1
XFILLER_111_626 VGND VGND VPWR VPWR sky130_fd_sc_hd__decap_3
XFILLER_110_136 VGND VGND VPWR VPWR sky130_fd_sc_hd__decap_3
XFILLER_110_147 VGND VGND VPWR VPWR sky130_fd_sc_hd__decap_3
XFILLER_111_659 VGND VGND VPWR VPWR sky130_fd_sc_hd__decap_3
XFILLER_2_11 VGND VGND VPWR VPWR sky130_fd_sc_hd__decap_3
XFILLER_2_44 VGND VGND VPWR VPWR sky130_fd_sc_hd__decap_3
XFILLER_49_242 VGND VGND VPWR VPWR sky130_fd_sc_hd__decap_3
XFILLER_96_359 VGND VGND VPWR VPWR sky130_fd_sc_hd__fill_2
XFILLER_2_77 VGND VGND VPWR VPWR sky130_fd_sc_hd__decap_3
XFILLER_49_264 VGND VGND VPWR VPWR sky130_fd_sc_hd__decap_3
XFILLER_2_88 VGND VGND VPWR VPWR sky130_fd_sc_hd__decap_3
XFILLER_64_223 VGND VGND VPWR VPWR sky130_fd_sc_hd__fill_1
XFILLER_18_640 VGND VGND VPWR VPWR sky130_fd_sc_hd__decap_3
XFILLER_18_651 VGND VGND VPWR VPWR sky130_fd_sc_hd__fill_1
XFILLER_64_256 VGND VGND VPWR VPWR sky130_fd_sc_hd__decap_3
XTAP_TAPCELL_ROW_69_1079 VGND VPWR sky130_fd_sc_hd__tapvpwrvgnd_1
XFILLER_17_172 VGND VGND VPWR VPWR sky130_fd_sc_hd__decap_3
XFILLER_24_109 VGND VGND VPWR VPWR sky130_fd_sc_hd__decap_3
XFILLER_64_289 VGND VGND VPWR VPWR sky130_fd_sc_hd__fill_2
XFILLER_92_587 VGND VGND VPWR VPWR sky130_fd_sc_hd__fill_1
X_4930_ _6995_/Q _4963_/A _6996_/Q VGND VGND VPWR VPWR _4931_/B sky130_fd_sc_hd__a21oi_2
XFILLER_17_194 VGND VGND VPWR VPWR sky130_fd_sc_hd__decap_3
XFILLER_33_665 VGND VGND VPWR VPWR sky130_fd_sc_hd__decap_3
XFILLER_45_492 VGND VGND VPWR VPWR sky130_fd_sc_hd__fill_2
X_4861_ _6998_/Q _6999_/Q _4912_/A _7000_/Q VGND VGND VPWR VPWR _4862_/B sky130_fd_sc_hd__a31o_2
XTAP_TAPCELL_ROW_82_1235 VGND VPWR sky130_fd_sc_hd__tapvpwrvgnd_1
X_6600_ _6600_/A VGND VGND VPWR VPWR _6600_/Y sky130_fd_sc_hd__inv_2
X_3812_ _3725_/X _3804_/X _3806_/X _3728_/Y _3811_/X VGND VGND VPWR VPWR _3812_/X
+ sky130_fd_sc_hd__a221o_2
XFILLER_32_197 VGND VGND VPWR VPWR sky130_fd_sc_hd__decap_3
XFILLER_60_495 VGND VGND VPWR VPWR sky130_fd_sc_hd__fill_2
X_4792_ _4997_/A1 _7004_/D _4777_/X _4791_/Y VGND VGND VPWR VPWR _4792_/X sky130_fd_sc_hd__a211o_2
X_6531_ _6532_/A VGND VGND VPWR VPWR _6531_/Y sky130_fd_sc_hd__inv_2
X_3743_ _6848_/Q _3892_/A2 _3651_/Y _6838_/Q _3742_/X VGND VGND VPWR VPWR _3743_/X
+ sky130_fd_sc_hd__a221o_2
X_6462_ _6652_/A VGND VGND VPWR VPWR _6462_/Y sky130_fd_sc_hd__inv_2
X_3674_ _6806_/Q VGND VGND VPWR VPWR _3674_/Y sky130_fd_sc_hd__inv_2
XFILLER_9_393 VGND VGND VPWR VPWR sky130_fd_sc_hd__decap_3
XFILLER_9_382 VGND VGND VPWR VPWR sky130_fd_sc_hd__decap_3
X_6393_ _6553_/A VGND VGND VPWR VPWR _6393_/Y sky130_fd_sc_hd__inv_2
X_5413_ _7127_/Q _5107_/X _5423_/S VGND VGND VPWR VPWR _7127_/D sky130_fd_sc_hd__mux2_2
X_5344_ _5344_/A0 _5107_/X _5358_/S VGND VGND VPWR VPWR _7159_/D sky130_fd_sc_hd__mux2_2
XTAP_TAPCELL_ROW_93_1364 VGND VPWR sky130_fd_sc_hd__tapvpwrvgnd_1
XFILLER_102_648 VGND VGND VPWR VPWR sky130_fd_sc_hd__decap_3
XFILLER_87_337 VGND VGND VPWR VPWR sky130_fd_sc_hd__decap_3
X_7014_ _7312_/CLK _7014_/D _6294_/Y VGND VGND VPWR VPWR _7014_/Q sky130_fd_sc_hd__dfrtp_2
X_4226_ _4372_/A _4627_/A VGND VGND VPWR VPWR _4620_/A sky130_fd_sc_hd__nor2_2
XFILLER_101_169 VGND VGND VPWR VPWR sky130_fd_sc_hd__decap_3
XFILLER_28_404 VGND VGND VPWR VPWR sky130_fd_sc_hd__decap_3
X_4157_ _4157_/A _4205_/C VGND VGND VPWR VPWR _4158_/B sky130_fd_sc_hd__nand2_2
XFILLER_110_681 VGND VGND VPWR VPWR sky130_fd_sc_hd__decap_3
XFILLER_46_17 VGND VGND VPWR VPWR sky130_fd_sc_hd__decap_3
XFILLER_55_201 VGND VGND VPWR VPWR sky130_fd_sc_hd__decap_3
XFILLER_68_595 VGND VGND VPWR VPWR sky130_fd_sc_hd__fill_2
XFILLER_102_12 VGND VGND VPWR VPWR sky130_fd_sc_hd__decap_3
XFILLER_55_245 VGND VGND VPWR VPWR sky130_fd_sc_hd__decap_3
X_4088_ _7238_/Q _4433_/B _4493_/S _7051_/Q VGND VGND VPWR VPWR _4088_/X sky130_fd_sc_hd__a22o_2
XTAP_TAPCELL_ROW_54_903 VGND VPWR sky130_fd_sc_hd__tapvpwrvgnd_1
XFILLER_83_598 VGND VGND VPWR VPWR sky130_fd_sc_hd__decap_3
XFILLER_102_67 VGND VGND VPWR VPWR sky130_fd_sc_hd__decap_3
XFILLER_62_27 VGND VGND VPWR VPWR sky130_fd_sc_hd__fill_1
XFILLER_23_142 VGND VGND VPWR VPWR sky130_fd_sc_hd__decap_3
XFILLER_23_153 VGND VGND VPWR VPWR sky130_fd_sc_hd__fill_1
XTAP_TAPCELL_ROW_34_660 VGND VPWR sky130_fd_sc_hd__tapvpwrvgnd_1
XFILLER_11_337 VGND VGND VPWR VPWR sky130_fd_sc_hd__decap_3
XFILLER_23_175 VGND VGND VPWR VPWR sky130_fd_sc_hd__decap_3
XTAP_TAPCELL_ROW_62_991 VGND VPWR sky130_fd_sc_hd__tapvpwrvgnd_1
XTAP_TAPCELL_ROW_102_1471 VGND VPWR sky130_fd_sc_hd__tapvpwrvgnd_1
X_6729_ _6909_/CLK _6729_/D VGND VGND VPWR VPWR _6729_/Q sky130_fd_sc_hd__dfxtp_2
XFILLER_109_258 VGND VGND VPWR VPWR sky130_fd_sc_hd__fill_1
XFILLER_11_42 VGND VGND VPWR VPWR sky130_fd_sc_hd__decap_3
XFILLER_11_75 VGND VGND VPWR VPWR sky130_fd_sc_hd__decap_3
XFILLER_3_558 VGND VGND VPWR VPWR sky130_fd_sc_hd__fill_2
XFILLER_87_24 VGND VGND VPWR VPWR sky130_fd_sc_hd__decap_3
XFILLER_78_315 VGND VGND VPWR VPWR sky130_fd_sc_hd__decap_3
XFILLER_87_57 VGND VGND VPWR VPWR sky130_fd_sc_hd__decap_3
XFILLER_78_359 VGND VGND VPWR VPWR sky130_fd_sc_hd__fill_2
XFILLER_46_212 VGND VGND VPWR VPWR sky130_fd_sc_hd__decap_3
XFILLER_59_584 VGND VGND VPWR VPWR sky130_fd_sc_hd__decap_3
XFILLER_86_392 VGND VGND VPWR VPWR sky130_fd_sc_hd__decap_3
XFILLER_100_191 VGND VGND VPWR VPWR sky130_fd_sc_hd__decap_3
XFILLER_46_245 VGND VGND VPWR VPWR sky130_fd_sc_hd__decap_3
XFILLER_46_256 VGND VGND VPWR VPWR sky130_fd_sc_hd__decap_3
XFILLER_74_565 VGND VGND VPWR VPWR sky130_fd_sc_hd__decap_3
XFILLER_15_610 VGND VGND VPWR VPWR sky130_fd_sc_hd__decap_3
XFILLER_27_481 VGND VGND VPWR VPWR sky130_fd_sc_hd__fill_1
XFILLER_46_278 VGND VGND VPWR VPWR sky130_fd_sc_hd__decap_3
XFILLER_74_598 VGND VGND VPWR VPWR sky130_fd_sc_hd__decap_3
XFILLER_14_120 VGND VGND VPWR VPWR sky130_fd_sc_hd__decap_3
XFILLER_30_613 VGND VGND VPWR VPWR sky130_fd_sc_hd__fill_1
XFILLER_42_451 VGND VGND VPWR VPWR sky130_fd_sc_hd__decap_3
XFILLER_99_9 VGND VGND VPWR VPWR sky130_fd_sc_hd__decap_3
XFILLER_14_197 VGND VGND VPWR VPWR sky130_fd_sc_hd__decap_3
XFILLER_30_635 VGND VGND VPWR VPWR sky130_fd_sc_hd__decap_3
XFILLER_52_71 VGND VGND VPWR VPWR sky130_fd_sc_hd__decap_3
Xhold809 _6978_/Q VGND VGND VPWR VPWR _6978_/D sky130_fd_sc_hd__dlygate4sd3_1
XTAP_TAPCELL_ROW_12_398 VGND VPWR sky130_fd_sc_hd__tapvpwrvgnd_1
XFILLER_115_217 VGND VGND VPWR VPWR sky130_fd_sc_hd__decap_3
XFILLER_115_228 VGND VGND VPWR VPWR sky130_fd_sc_hd__decap_3
X_3390_ _7155_/Q _4339_/B1 _3379_/X _3389_/X VGND VGND VPWR VPWR _3390_/X sky130_fd_sc_hd__a211o_2
XFILLER_96_112 VGND VGND VPWR VPWR sky130_fd_sc_hd__decap_3
XFILLER_97_635 VGND VGND VPWR VPWR sky130_fd_sc_hd__decap_3
XFILLER_69_348 VGND VGND VPWR VPWR sky130_fd_sc_hd__decap_3
X_5060_ _5581_/S _5045_/X _5059_/X _4467_/B VGND VGND VPWR VPWR _5060_/X sky130_fd_sc_hd__a22o_2
XFILLER_97_668 VGND VGND VPWR VPWR sky130_fd_sc_hd__decap_3
XFILLER_28_3 VGND VGND VPWR VPWR sky130_fd_sc_hd__decap_3
XFILLER_84_307 VGND VGND VPWR VPWR sky130_fd_sc_hd__fill_1
XFILLER_96_156 VGND VGND VPWR VPWR sky130_fd_sc_hd__fill_2
X_4011_ _7342_/Q _3935_/S _4437_/B1 _7374_/Q _4429_/C1 VGND VGND VPWR VPWR _4011_/X
+ sky130_fd_sc_hd__a221o_2
XFILLER_97_679 VGND VGND VPWR VPWR sky130_fd_sc_hd__decap_3
XFILLER_37_201 VGND VGND VPWR VPWR sky130_fd_sc_hd__decap_3
XFILLER_77_370 VGND VGND VPWR VPWR sky130_fd_sc_hd__decap_3
XFILLER_37_245 VGND VGND VPWR VPWR sky130_fd_sc_hd__decap_3
XFILLER_65_554 VGND VGND VPWR VPWR sky130_fd_sc_hd__decap_3
XFILLER_92_351 VGND VGND VPWR VPWR sky130_fd_sc_hd__fill_1
XFILLER_25_429 VGND VGND VPWR VPWR sky130_fd_sc_hd__decap_3
XFILLER_37_278 VGND VGND VPWR VPWR sky130_fd_sc_hd__fill_2
XFILLER_52_226 VGND VGND VPWR VPWR sky130_fd_sc_hd__decap_3
XFILLER_80_513 VGND VGND VPWR VPWR sky130_fd_sc_hd__decap_3
XFILLER_52_237 VGND VGND VPWR VPWR sky130_fd_sc_hd__decap_3
XFILLER_52_259 VGND VGND VPWR VPWR sky130_fd_sc_hd__decap_3
XFILLER_92_395 VGND VGND VPWR VPWR sky130_fd_sc_hd__decap_3
X_4913_ _5657_/B _3762_/X _4910_/Y _6997_/D _3341_/A VGND VGND VPWR VPWR _4913_/X
+ sky130_fd_sc_hd__o32a_2
XFILLER_33_462 VGND VGND VPWR VPWR sky130_fd_sc_hd__decap_3
XFILLER_20_123 VGND VGND VPWR VPWR sky130_fd_sc_hd__decap_3
XFILLER_32_19 VGND VGND VPWR VPWR sky130_fd_sc_hd__decap_3
X_4844_ _4633_/A _4111_/B _4842_/X _4843_/Y _4948_/A VGND VGND VPWR VPWR _4855_/A
+ sky130_fd_sc_hd__a311oi_2
XFILLER_20_134 VGND VGND VPWR VPWR sky130_fd_sc_hd__decap_3
X_4775_ _4775_/A _4775_/B VGND VGND VPWR VPWR _7004_/D sky130_fd_sc_hd__nor2_2
X_6514_ _6578_/A VGND VGND VPWR VPWR _6514_/Y sky130_fd_sc_hd__inv_2
X_3726_ _3714_/X _3721_/X _3724_/X _3725_/X VGND VGND VPWR VPWR _3726_/X sky130_fd_sc_hd__a22o_2
XFILLER_106_228 VGND VGND VPWR VPWR sky130_fd_sc_hd__decap_3
XFILLER_106_239 VGND VGND VPWR VPWR sky130_fd_sc_hd__decap_3
X_6445_ _6604_/A VGND VGND VPWR VPWR _6445_/Y sky130_fd_sc_hd__inv_2
X_6376_ _6568_/A VGND VGND VPWR VPWR _6376_/Y sky130_fd_sc_hd__inv_2
XFILLER_102_412 VGND VGND VPWR VPWR sky130_fd_sc_hd__decap_3
XFILLER_87_101 VGND VGND VPWR VPWR sky130_fd_sc_hd__decap_3
XFILLER_88_602 VGND VGND VPWR VPWR sky130_fd_sc_hd__decap_3
XFILLER_88_635 VGND VGND VPWR VPWR sky130_fd_sc_hd__decap_3
X_5327_ _5327_/A0 _4978_/X _7412_/A VGND VGND VPWR VPWR _7167_/D sky130_fd_sc_hd__mux2_2
XFILLER_0_539 VGND VGND VPWR VPWR sky130_fd_sc_hd__fill_1
XFILLER_102_445 VGND VGND VPWR VPWR sky130_fd_sc_hd__decap_3
XFILLER_114_283 VGND VGND VPWR VPWR sky130_fd_sc_hd__decap_3
XFILLER_87_134 VGND VGND VPWR VPWR sky130_fd_sc_hd__decap_3
XFILLER_88_657 VGND VGND VPWR VPWR sky130_fd_sc_hd__decap_3
XFILLER_87_178 VGND VGND VPWR VPWR sky130_fd_sc_hd__fill_1
X_5258_ _5258_/A0 _4945_/X _5262_/S VGND VGND VPWR VPWR _7201_/D sky130_fd_sc_hd__mux2_2
XFILLER_28_212 VGND VGND VPWR VPWR sky130_fd_sc_hd__fill_2
XFILLER_68_381 VGND VGND VPWR VPWR sky130_fd_sc_hd__decap_3
XFILLER_75_329 VGND VGND VPWR VPWR sky130_fd_sc_hd__decap_3
XFILLER_96_690 VGND VGND VPWR VPWR sky130_fd_sc_hd__fill_2
X_4209_ _4633_/A _4903_/A _4845_/A _4890_/B VGND VGND VPWR VPWR _4384_/A sky130_fd_sc_hd__and4_2
XFILLER_113_33 VGND VGND VPWR VPWR sky130_fd_sc_hd__decap_3
XFILLER_28_234 VGND VGND VPWR VPWR sky130_fd_sc_hd__decap_3
XFILLER_28_256 VGND VGND VPWR VPWR sky130_fd_sc_hd__decap_3
XFILLER_113_66 VGND VGND VPWR VPWR sky130_fd_sc_hd__decap_3
XFILLER_28_289 VGND VGND VPWR VPWR sky130_fd_sc_hd__decap_3
XFILLER_43_204 VGND VGND VPWR VPWR sky130_fd_sc_hd__decap_3
XFILLER_56_587 VGND VGND VPWR VPWR sky130_fd_sc_hd__fill_1
XFILLER_56_598 VGND VGND VPWR VPWR sky130_fd_sc_hd__decap_3
XFILLER_71_513 VGND VGND VPWR VPWR sky130_fd_sc_hd__decap_3
XFILLER_73_15 VGND VGND VPWR VPWR sky130_fd_sc_hd__fill_1
XFILLER_73_37 VGND VGND VPWR VPWR sky130_fd_sc_hd__decap_3
XTAP_TAPCELL_ROW_104_1500 VGND VPWR sky130_fd_sc_hd__tapvpwrvgnd_1
XFILLER_113_99 VGND VGND VPWR VPWR sky130_fd_sc_hd__decap_3
XFILLER_71_535 VGND VGND VPWR VPWR sky130_fd_sc_hd__decap_3
XFILLER_71_579 VGND VGND VPWR VPWR sky130_fd_sc_hd__fill_2
XFILLER_51_270 VGND VGND VPWR VPWR sky130_fd_sc_hd__decap_3
XFILLER_12_668 VGND VGND VPWR VPWR sky130_fd_sc_hd__decap_3
XFILLER_7_105 VGND VGND VPWR VPWR sky130_fd_sc_hd__decap_3
XPHY_EDGE_ROW_91_Left_208 VGND VGND VPWR VPWR sky130_fd_sc_hd__decap_3
XFILLER_11_167 VGND VGND VPWR VPWR sky130_fd_sc_hd__fill_1
XFILLER_7_116 VGND VGND VPWR VPWR sky130_fd_sc_hd__decap_3
XFILLER_7_149 VGND VGND VPWR VPWR sky130_fd_sc_hd__decap_3
XFILLER_98_12 VGND VGND VPWR VPWR sky130_fd_sc_hd__decap_3
XFILLER_98_56 VGND VGND VPWR VPWR sky130_fd_sc_hd__decap_3
XFILLER_105_261 VGND VGND VPWR VPWR sky130_fd_sc_hd__decap_3
XFILLER_112_209 VGND VGND VPWR VPWR sky130_fd_sc_hd__decap_3
XFILLER_3_366 VGND VGND VPWR VPWR sky130_fd_sc_hd__decap_3
XFILLER_79_602 VGND VGND VPWR VPWR sky130_fd_sc_hd__decap_3
XFILLER_3_399 VGND VGND VPWR VPWR sky130_fd_sc_hd__decap_3
XFILLER_79_635 VGND VGND VPWR VPWR sky130_fd_sc_hd__decap_3
XFILLER_79_668 VGND VGND VPWR VPWR sky130_fd_sc_hd__decap_3
XFILLER_78_156 VGND VGND VPWR VPWR sky130_fd_sc_hd__decap_3
XFILLER_79_679 VGND VGND VPWR VPWR sky130_fd_sc_hd__decap_3
XFILLER_94_627 VGND VGND VPWR VPWR sky130_fd_sc_hd__decap_3
XFILLER_14_9 VGND VGND VPWR VPWR sky130_fd_sc_hd__decap_3
XFILLER_19_245 VGND VGND VPWR VPWR sky130_fd_sc_hd__decap_3
XFILLER_47_543 VGND VGND VPWR VPWR sky130_fd_sc_hd__decap_3
XFILLER_47_60 VGND VGND VPWR VPWR sky130_fd_sc_hd__fill_1
XFILLER_74_351 VGND VGND VPWR VPWR sky130_fd_sc_hd__fill_2
XFILLER_34_215 VGND VGND VPWR VPWR sky130_fd_sc_hd__decap_3
XFILLER_47_598 VGND VGND VPWR VPWR sky130_fd_sc_hd__decap_3
XFILLER_34_237 VGND VGND VPWR VPWR sky130_fd_sc_hd__decap_3
XTAP_TAPCELL_ROW_66_1049 VGND VPWR sky130_fd_sc_hd__tapvpwrvgnd_1
XTAP_TAPCELL_ROW_66_1038 VGND VPWR sky130_fd_sc_hd__tapvpwrvgnd_1
XFILLER_62_579 VGND VGND VPWR VPWR sky130_fd_sc_hd__decap_3
XFILLER_63_70 VGND VGND VPWR VPWR sky130_fd_sc_hd__decap_3
XTAP_TAPCELL_ROW_45_788 VGND VPWR sky130_fd_sc_hd__tapvpwrvgnd_1
XTAP_TAPCELL_ROW_17_457 VGND VPWR sky130_fd_sc_hd__tapvpwrvgnd_1
XFILLER_42_281 VGND VGND VPWR VPWR sky130_fd_sc_hd__decap_3
XFILLER_97_6 VGND VGND VPWR VPWR sky130_fd_sc_hd__decap_3
XFILLER_8_32 VGND VGND VPWR VPWR sky130_fd_sc_hd__decap_3
XFILLER_8_65 VGND VGND VPWR VPWR sky130_fd_sc_hd__decap_3
Xhold606 _6867_/Q VGND VGND VPWR VPWR _6867_/D sky130_fd_sc_hd__dlygate4sd3_1
Xhold617 _6868_/Q VGND VGND VPWR VPWR _6868_/D sky130_fd_sc_hd__dlygate4sd3_1
X_4491_ _4491_/A0 _4556_/A _4493_/S VGND VGND VPWR VPWR _7334_/D sky130_fd_sc_hd__mux2_2
XFILLER_116_548 VGND VGND VPWR VPWR sky130_fd_sc_hd__decap_3
XFILLER_6_182 VGND VGND VPWR VPWR sky130_fd_sc_hd__decap_3
Xhold628 _6889_/Q VGND VGND VPWR VPWR _6889_/D sky130_fd_sc_hd__dlygate4sd3_1
Xhold639 _6737_/Q VGND VGND VPWR VPWR _6737_/D sky130_fd_sc_hd__dlygate4sd3_1
X_3442_ _3442_/A _3442_/B VGND VGND VPWR VPWR _4394_/A sky130_fd_sc_hd__nand2_2
XTAP_TAPCELL_ROW_77_1178 VGND VPWR sky130_fd_sc_hd__tapvpwrvgnd_1
X_3373_ _3560_/B _3370_/Y _3977_/S VGND VGND VPWR VPWR _3429_/A sky130_fd_sc_hd__a21o_2
XFILLER_111_220 VGND VGND VPWR VPWR sky130_fd_sc_hd__decap_3
X_5112_ _4292_/A _3594_/B _4295_/X VGND VGND VPWR VPWR _5113_/B sky130_fd_sc_hd__a21oi_2
XTAP_TAPCELL_ROW_90_1334 VGND VPWR sky130_fd_sc_hd__tapvpwrvgnd_1
XFILLER_85_605 VGND VGND VPWR VPWR sky130_fd_sc_hd__decap_3
XFILLER_97_476 VGND VGND VPWR VPWR sky130_fd_sc_hd__decap_3
XFILLER_111_275 VGND VGND VPWR VPWR sky130_fd_sc_hd__fill_2
XFILLER_69_178 VGND VGND VPWR VPWR sky130_fd_sc_hd__decap_3
XFILLER_84_126 VGND VGND VPWR VPWR sky130_fd_sc_hd__decap_3
XFILLER_85_638 VGND VGND VPWR VPWR sky130_fd_sc_hd__decap_3
X_5043_ _6988_/Q _5066_/A VGND VGND VPWR VPWR _5044_/B sky130_fd_sc_hd__nor2_2
XFILLER_38_554 VGND VGND VPWR VPWR sky130_fd_sc_hd__decap_3
XFILLER_65_340 VGND VGND VPWR VPWR sky130_fd_sc_hd__decap_3
XFILLER_65_384 VGND VGND VPWR VPWR sky130_fd_sc_hd__decap_3
XFILLER_93_671 VGND VGND VPWR VPWR sky130_fd_sc_hd__fill_1
XFILLER_80_321 VGND VGND VPWR VPWR sky130_fd_sc_hd__decap_3
XFILLER_80_343 VGND VGND VPWR VPWR sky130_fd_sc_hd__decap_3
X_6994_ _7398_/CLK _6994_/D _6274_/Y VGND VGND VPWR VPWR _6994_/Q sky130_fd_sc_hd__dfrtp_2
XFILLER_25_259 VGND VGND VPWR VPWR sky130_fd_sc_hd__fill_2
XFILLER_43_18 VGND VGND VPWR VPWR sky130_fd_sc_hd__decap_3
XFILLER_80_365 VGND VGND VPWR VPWR sky130_fd_sc_hd__decap_3
XFILLER_33_281 VGND VGND VPWR VPWR sky130_fd_sc_hd__fill_2
XFILLER_61_590 VGND VGND VPWR VPWR sky130_fd_sc_hd__decap_3
XFILLER_80_398 VGND VGND VPWR VPWR sky130_fd_sc_hd__fill_1
X_4827_ _4827_/A _4827_/B VGND VGND VPWR VPWR _4827_/X sky130_fd_sc_hd__xor2_2
XFILLER_5_609 VGND VGND VPWR VPWR sky130_fd_sc_hd__decap_3
X_4758_ _7004_/Q _4804_/A VGND VGND VPWR VPWR _4777_/B sky130_fd_sc_hd__nand2_2
XFILLER_107_526 VGND VGND VPWR VPWR sky130_fd_sc_hd__decap_3
X_4689_ _7002_/Q _4834_/A _4688_/X _7003_/Q VGND VGND VPWR VPWR _4804_/A sky130_fd_sc_hd__o211a_2
X_3709_ _3629_/A _3708_/X _3442_/A VGND VGND VPWR VPWR _3709_/X sky130_fd_sc_hd__a21o_2
XFILLER_108_44 VGND VGND VPWR VPWR sky130_fd_sc_hd__decap_3
X_6428_ _6558_/A VGND VGND VPWR VPWR _6428_/Y sky130_fd_sc_hd__inv_2
XFILLER_108_77 VGND VGND VPWR VPWR sky130_fd_sc_hd__decap_3
XFILLER_115_570 VGND VGND VPWR VPWR sky130_fd_sc_hd__decap_3
XFILLER_68_26 VGND VGND VPWR VPWR sky130_fd_sc_hd__fill_2
XFILLER_88_410 VGND VGND VPWR VPWR sky130_fd_sc_hd__decap_3
XFILLER_108_88 VGND VGND VPWR VPWR sky130_fd_sc_hd__decap_3
X_6359_ _6385_/A VGND VGND VPWR VPWR _6359_/Y sky130_fd_sc_hd__inv_2
XFILLER_102_242 VGND VGND VPWR VPWR sky130_fd_sc_hd__decap_3
XFILLER_102_253 VGND VGND VPWR VPWR sky130_fd_sc_hd__decap_3
XFILLER_88_454 VGND VGND VPWR VPWR sky130_fd_sc_hd__fill_2
XFILLER_88_465 VGND VGND VPWR VPWR sky130_fd_sc_hd__fill_1
XFILLER_102_286 VGND VGND VPWR VPWR sky130_fd_sc_hd__decap_3
XFILLER_48_318 VGND VGND VPWR VPWR sky130_fd_sc_hd__decap_3
XFILLER_75_104 VGND VGND VPWR VPWR sky130_fd_sc_hd__decap_3
XFILLER_88_498 VGND VGND VPWR VPWR sky130_fd_sc_hd__fill_2
XTAP_TAPCELL_ROW_110_1570 VGND VPWR sky130_fd_sc_hd__tapvpwrvgnd_1
XFILLER_84_47 VGND VGND VPWR VPWR sky130_fd_sc_hd__decap_3
XFILLER_91_608 VGND VGND VPWR VPWR sky130_fd_sc_hd__fill_1
XFILLER_16_215 VGND VGND VPWR VPWR sky130_fd_sc_hd__decap_3
XFILLER_17_30 VGND VGND VPWR VPWR sky130_fd_sc_hd__decap_3
XFILLER_84_58 VGND VGND VPWR VPWR sky130_fd_sc_hd__decap_3
XFILLER_84_660 VGND VGND VPWR VPWR sky130_fd_sc_hd__decap_3
XFILLER_17_52 VGND VGND VPWR VPWR sky130_fd_sc_hd__decap_3
XFILLER_17_63 VGND VGND VPWR VPWR sky130_fd_sc_hd__decap_3
XFILLER_56_395 VGND VGND VPWR VPWR sky130_fd_sc_hd__fill_2
XFILLER_71_310 VGND VGND VPWR VPWR sky130_fd_sc_hd__decap_3
XFILLER_16_259 VGND VGND VPWR VPWR sky130_fd_sc_hd__decap_3
XFILLER_71_365 VGND VGND VPWR VPWR sky130_fd_sc_hd__decap_3
XTAP_TAPCELL_ROW_14_416 VGND VPWR sky130_fd_sc_hd__tapvpwrvgnd_1
XFILLER_24_292 VGND VGND VPWR VPWR sky130_fd_sc_hd__decap_3
XTAP_TAPCELL_ROW_42_758 VGND VPWR sky130_fd_sc_hd__tapvpwrvgnd_1
XFILLER_12_498 VGND VGND VPWR VPWR sky130_fd_sc_hd__decap_3
XFILLER_113_529 VGND VGND VPWR VPWR sky130_fd_sc_hd__decap_3
XFILLER_3_152 VGND VGND VPWR VPWR sky130_fd_sc_hd__decap_3
XFILLER_4_675 VGND VGND VPWR VPWR sky130_fd_sc_hd__decap_3
XFILLER_58_81 VGND VGND VPWR VPWR sky130_fd_sc_hd__decap_3
XFILLER_66_126 VGND VGND VPWR VPWR sky130_fd_sc_hd__decap_3
XFILLER_67_638 VGND VGND VPWR VPWR sky130_fd_sc_hd__decap_3
XFILLER_79_487 VGND VGND VPWR VPWR sky130_fd_sc_hd__decap_3
XFILLER_94_424 VGND VGND VPWR VPWR sky130_fd_sc_hd__fill_2
XFILLER_12_6 VGND VGND VPWR VPWR sky130_fd_sc_hd__decap_3
XFILLER_66_159 VGND VGND VPWR VPWR sky130_fd_sc_hd__decap_3
XFILLER_82_619 VGND VGND VPWR VPWR sky130_fd_sc_hd__decap_3
XFILLER_94_468 VGND VGND VPWR VPWR sky130_fd_sc_hd__fill_1
XFILLER_75_660 VGND VGND VPWR VPWR sky130_fd_sc_hd__decap_3
XFILLER_75_682 VGND VGND VPWR VPWR sky130_fd_sc_hd__decap_3
XFILLER_62_365 VGND VGND VPWR VPWR sky130_fd_sc_hd__decap_3
XFILLER_90_663 VGND VGND VPWR VPWR sky130_fd_sc_hd__decap_3
X_3991_ _5151_/A _3991_/B VGND VGND VPWR VPWR _3991_/X sky130_fd_sc_hd__or2_2
XFILLER_22_229 VGND VGND VPWR VPWR sky130_fd_sc_hd__decap_3
XFILLER_62_387 VGND VGND VPWR VPWR sky130_fd_sc_hd__decap_3
XFILLER_95_3 VGND VGND VPWR VPWR sky130_fd_sc_hd__decap_3
XFILLER_15_281 VGND VGND VPWR VPWR sky130_fd_sc_hd__decap_3
XFILLER_30_251 VGND VGND VPWR VPWR sky130_fd_sc_hd__fill_1
XFILLER_30_262 VGND VGND VPWR VPWR sky130_fd_sc_hd__decap_3
X_7400_ _7403_/CLK _7400_/D _6680_/Y VGND VGND VPWR VPWR _7400_/Q sky130_fd_sc_hd__dfrtp_2
X_5661_ _5661_/A _5661_/B _5661_/C _5661_/D VGND VGND VPWR VPWR _5661_/X sky130_fd_sc_hd__and4_2
XFILLER_30_295 VGND VGND VPWR VPWR sky130_fd_sc_hd__decap_3
X_4612_ _4612_/A _4612_/B VGND VGND VPWR VPWR _5114_/B sky130_fd_sc_hd__nor2_2
XFILLER_116_301 VGND VGND VPWR VPWR sky130_fd_sc_hd__decap_3
X_7331_ _7363_/CLK _7331_/D _6611_/Y VGND VGND VPWR VPWR _7331_/Q sky130_fd_sc_hd__dfrtp_2
XFILLER_116_356 VGND VGND VPWR VPWR sky130_fd_sc_hd__decap_3
X_7262_ _7294_/CLK _7262_/D _6542_/Y VGND VGND VPWR VPWR _7262_/Q sky130_fd_sc_hd__dfrtp_2
X_4474_ _4474_/A0 _4540_/A _4488_/S VGND VGND VPWR VPWR _7342_/D sky130_fd_sc_hd__mux2_2
X_7193_ _7360_/CLK _7193_/D _6473_/Y VGND VGND VPWR VPWR _7193_/Q sky130_fd_sc_hd__dfrtp_2
X_3425_ _3589_/A _3591_/A _3589_/B _3590_/C VGND VGND VPWR VPWR _3527_/A sky130_fd_sc_hd__o31a_2
XFILLER_112_551 VGND VGND VPWR VPWR sky130_fd_sc_hd__decap_3
XFILLER_38_18 VGND VGND VPWR VPWR sky130_fd_sc_hd__decap_3
XFILLER_58_616 VGND VGND VPWR VPWR sky130_fd_sc_hd__decap_3
X_3356_ _5118_/D _3354_/X _3355_/Y _3342_/B VGND VGND VPWR VPWR _4537_/B sky130_fd_sc_hd__a22o_2
XFILLER_112_584 VGND VGND VPWR VPWR sky130_fd_sc_hd__decap_3
XFILLER_112_595 VGND VGND VPWR VPWR sky130_fd_sc_hd__decap_3
XFILLER_85_413 VGND VGND VPWR VPWR sky130_fd_sc_hd__decap_3
XFILLER_97_284 VGND VGND VPWR VPWR sky130_fd_sc_hd__decap_3
Xhold1103 _7252_/Q VGND VGND VPWR VPWR _5132_/A0 sky130_fd_sc_hd__dlygate4sd3_1
Xhold1114 _7298_/Q VGND VGND VPWR VPWR _4565_/A sky130_fd_sc_hd__dlygate4sd3_1
XFILLER_73_608 VGND VGND VPWR VPWR sky130_fd_sc_hd__decap_3
Xhold1125 _7168_/Q VGND VGND VPWR VPWR _5325_/A0 sky130_fd_sc_hd__dlygate4sd3_1
Xhold1136 _7297_/Q VGND VGND VPWR VPWR _4567_/A sky130_fd_sc_hd__dlygate4sd3_1
Xhold1147 _7219_/Q VGND VGND VPWR VPWR _5219_/A sky130_fd_sc_hd__dlygate4sd3_1
Xhold1158 _7153_/Q VGND VGND VPWR VPWR _5356_/A0 sky130_fd_sc_hd__dlygate4sd3_1
X_5026_ _5026_/A _5026_/B VGND VGND VPWR VPWR _6990_/D sky130_fd_sc_hd__nor2_2
XFILLER_38_351 VGND VGND VPWR VPWR sky130_fd_sc_hd__decap_3
XFILLER_38_373 VGND VGND VPWR VPWR sky130_fd_sc_hd__decap_3
XFILLER_66_660 VGND VGND VPWR VPWR sky130_fd_sc_hd__decap_3
Xhold1169 _7328_/Q VGND VGND VPWR VPWR _4503_/A0 sky130_fd_sc_hd__dlygate4sd3_1
XFILLER_53_310 VGND VGND VPWR VPWR sky130_fd_sc_hd__decap_3
XFILLER_54_39 VGND VGND VPWR VPWR sky130_fd_sc_hd__decap_3
XFILLER_65_181 VGND VGND VPWR VPWR sky130_fd_sc_hd__decap_3
XFILLER_81_641 VGND VGND VPWR VPWR sky130_fd_sc_hd__decap_3
X_6977_ clkload2/A _6977_/D VGND VGND VPWR VPWR _6977_/Q sky130_fd_sc_hd__dfxtp_2
XFILLER_110_12 VGND VGND VPWR VPWR sky130_fd_sc_hd__decap_3
XFILLER_53_387 VGND VGND VPWR VPWR sky130_fd_sc_hd__decap_3
XFILLER_81_685 VGND VGND VPWR VPWR sky130_fd_sc_hd__decap_3
XFILLER_110_56 VGND VGND VPWR VPWR sky130_fd_sc_hd__decap_3
XFILLER_21_240 VGND VGND VPWR VPWR sky130_fd_sc_hd__decap_3
XFILLER_70_27 VGND VGND VPWR VPWR sky130_fd_sc_hd__fill_1
XFILLER_70_49 VGND VGND VPWR VPWR sky130_fd_sc_hd__decap_3
XFILLER_21_284 VGND VGND VPWR VPWR sky130_fd_sc_hd__decap_3
XFILLER_5_417 VGND VGND VPWR VPWR sky130_fd_sc_hd__decap_3
XFILLER_79_14 VGND VGND VPWR VPWR sky130_fd_sc_hd__decap_3
XFILLER_79_69 VGND VGND VPWR VPWR sky130_fd_sc_hd__decap_3
XFILLER_1_612 VGND VGND VPWR VPWR sky130_fd_sc_hd__decap_3
XFILLER_1_634 VGND VGND VPWR VPWR sky130_fd_sc_hd__decap_3
Xhold981 _7390_/Q VGND VGND VPWR VPWR hold981/X sky130_fd_sc_hd__dlygate4sd3_1
Xhold970 _7035_/Q VGND VGND VPWR VPWR hold970/X sky130_fd_sc_hd__dlygate4sd3_1
XFILLER_0_144 VGND VGND VPWR VPWR sky130_fd_sc_hd__decap_3
XFILLER_103_540 VGND VGND VPWR VPWR sky130_fd_sc_hd__decap_3
XFILLER_1_667 VGND VGND VPWR VPWR sky130_fd_sc_hd__decap_3
Xhold992 _7024_/Q VGND VGND VPWR VPWR _5607_/A sky130_fd_sc_hd__dlygate4sd3_1
XFILLER_48_126 VGND VGND VPWR VPWR sky130_fd_sc_hd__fill_2
XFILLER_49_638 VGND VGND VPWR VPWR sky130_fd_sc_hd__decap_3
XFILLER_76_424 VGND VGND VPWR VPWR sky130_fd_sc_hd__decap_3
XFILLER_95_46 VGND VGND VPWR VPWR sky130_fd_sc_hd__fill_2
XFILLER_95_57 VGND VGND VPWR VPWR sky130_fd_sc_hd__decap_3
XFILLER_28_40 VGND VGND VPWR VPWR sky130_fd_sc_hd__decap_3
XFILLER_76_457 VGND VGND VPWR VPWR sky130_fd_sc_hd__decap_3
XFILLER_17_502 VGND VGND VPWR VPWR sky130_fd_sc_hd__fill_2
XFILLER_17_513 VGND VGND VPWR VPWR sky130_fd_sc_hd__decap_3
XFILLER_28_73 VGND VGND VPWR VPWR sky130_fd_sc_hd__decap_3
XFILLER_57_671 VGND VGND VPWR VPWR sky130_fd_sc_hd__fill_1
XFILLER_57_682 VGND VGND VPWR VPWR sky130_fd_sc_hd__decap_3
XFILLER_64_619 VGND VGND VPWR VPWR sky130_fd_sc_hd__decap_3
XFILLER_91_427 VGND VGND VPWR VPWR sky130_fd_sc_hd__fill_2
XTAP_TAPCELL_ROW_47_817 VGND VPWR sky130_fd_sc_hd__tapvpwrvgnd_1
XFILLER_17_546 VGND VGND VPWR VPWR sky130_fd_sc_hd__fill_2
XFILLER_28_95 VGND VGND VPWR VPWR sky130_fd_sc_hd__decap_3
XFILLER_29_384 VGND VGND VPWR VPWR sky130_fd_sc_hd__fill_1
XFILLER_44_332 VGND VGND VPWR VPWR sky130_fd_sc_hd__fill_1
XFILLER_72_630 VGND VGND VPWR VPWR sky130_fd_sc_hd__decap_3
XFILLER_91_449 VGND VGND VPWR VPWR sky130_fd_sc_hd__fill_1
XFILLER_17_557 VGND VGND VPWR VPWR sky130_fd_sc_hd__decap_3
XFILLER_44_365 VGND VGND VPWR VPWR sky130_fd_sc_hd__decap_3
XFILLER_72_663 VGND VGND VPWR VPWR sky130_fd_sc_hd__decap_3
XTAP_TAPCELL_ROW_63_1008 VGND VPWR sky130_fd_sc_hd__tapvpwrvgnd_1
XFILLER_32_527 VGND VGND VPWR VPWR sky130_fd_sc_hd__decap_3
XFILLER_44_61 VGND VGND VPWR VPWR sky130_fd_sc_hd__decap_3
XFILLER_71_162 VGND VGND VPWR VPWR sky130_fd_sc_hd__decap_3
XFILLER_71_184 VGND VGND VPWR VPWR sky130_fd_sc_hd__decap_3
XTAP_TAPCELL_ROW_27_574 VGND VPWR sky130_fd_sc_hd__tapvpwrvgnd_1
XFILLER_44_83 VGND VGND VPWR VPWR sky130_fd_sc_hd__fill_1
XFILLER_12_251 VGND VGND VPWR VPWR sky130_fd_sc_hd__fill_1
XFILLER_81_9 VGND VGND VPWR VPWR sky130_fd_sc_hd__decap_3
XFILLER_8_200 VGND VGND VPWR VPWR sky130_fd_sc_hd__fill_2
XFILLER_12_295 VGND VGND VPWR VPWR sky130_fd_sc_hd__decap_3
XFILLER_60_71 VGND VGND VPWR VPWR sky130_fd_sc_hd__fill_2
XFILLER_60_93 VGND VGND VPWR VPWR sky130_fd_sc_hd__decap_3
XFILLER_8_299 VGND VGND VPWR VPWR sky130_fd_sc_hd__decap_3
Xoutput508 _4522_/S VGND VGND VPWR VPWR instruction_out[24] sky130_fd_sc_hd__clkdlybuf4s25_1
XFILLER_5_33 VGND VGND VPWR VPWR sky130_fd_sc_hd__decap_3
Xoutput519 _5229_/B VGND VGND VPWR VPWR instruction_out[7] sky130_fd_sc_hd__clkdlybuf4s25_1
XTAP_TAPCELL_ROW_74_1137 VGND VPWR sky130_fd_sc_hd__tapvpwrvgnd_1
XFILLER_99_527 VGND VGND VPWR VPWR sky130_fd_sc_hd__decap_3
XFILLER_99_505 VGND VGND VPWR VPWR sky130_fd_sc_hd__decap_3
XFILLER_113_337 VGND VGND VPWR VPWR sky130_fd_sc_hd__decap_3
XFILLER_5_66 VGND VGND VPWR VPWR sky130_fd_sc_hd__decap_3
XFILLER_5_99 VGND VGND VPWR VPWR sky130_fd_sc_hd__decap_3
XFILLER_79_240 VGND VGND VPWR VPWR sky130_fd_sc_hd__decap_3
X_4190_ _7263_/Q _4418_/A2 _3378_/Y _7135_/Q _4189_/X VGND VGND VPWR VPWR _4637_/B
+ sky130_fd_sc_hd__a221o_2
XFILLER_67_424 VGND VGND VPWR VPWR sky130_fd_sc_hd__decap_3
XFILLER_10_3 VGND VGND VPWR VPWR sky130_fd_sc_hd__decap_3
XFILLER_48_660 VGND VGND VPWR VPWR sky130_fd_sc_hd__decap_3
XFILLER_54_118 VGND VGND VPWR VPWR sky130_fd_sc_hd__decap_3
XFILLER_82_405 VGND VGND VPWR VPWR sky130_fd_sc_hd__decap_3
XFILLER_82_427 VGND VGND VPWR VPWR sky130_fd_sc_hd__fill_1
XFILLER_63_641 VGND VGND VPWR VPWR sky130_fd_sc_hd__decap_3
XFILLER_82_449 VGND VGND VPWR VPWR sky130_fd_sc_hd__decap_3
XFILLER_94_298 VGND VGND VPWR VPWR sky130_fd_sc_hd__decap_3
X_6900_ _6944_/CLK _6900_/D VGND VGND VPWR VPWR _6900_/Q sky130_fd_sc_hd__dfxtp_2
XFILLER_23_505 VGND VGND VPWR VPWR sky130_fd_sc_hd__decap_3
X_6831_ _6946_/CLK _6831_/D VGND VGND VPWR VPWR _6831_/Q sky130_fd_sc_hd__dfxtp_2
XTAP_TAPCELL_ROW_85_1266 VGND VPWR sky130_fd_sc_hd__tapvpwrvgnd_1
XTAP_TAPCELL_ROW_85_1277 VGND VPWR sky130_fd_sc_hd__tapvpwrvgnd_1
XFILLER_62_195 VGND VGND VPWR VPWR sky130_fd_sc_hd__fill_1
X_6762_ _6971_/CLK _6762_/D VGND VGND VPWR VPWR _6762_/Q sky130_fd_sc_hd__dfxtp_2
XFILLER_50_368 VGND VGND VPWR VPWR sky130_fd_sc_hd__fill_2
XFILLER_50_379 VGND VGND VPWR VPWR sky130_fd_sc_hd__fill_1
X_6693_ _7383_/CLK _6693_/D VGND VGND VPWR VPWR _6693_/Q sky130_fd_sc_hd__dfxtp_2
X_5644_ _6981_/Q _5130_/C _3340_/B _6980_/Q VGND VGND VPWR VPWR _5644_/X sky130_fd_sc_hd__o211a_2
XFILLER_108_109 VGND VGND VPWR VPWR sky130_fd_sc_hd__decap_3
X_7314_ _7352_/CLK _7314_/D _6594_/Y VGND VGND VPWR VPWR _7314_/Q sky130_fd_sc_hd__dfrtp_2
X_5575_ hold984/X _5598_/A2 _5010_/D VGND VGND VPWR VPWR _7042_/D sky130_fd_sc_hd__a21o_2
XFILLER_116_164 VGND VGND VPWR VPWR sky130_fd_sc_hd__decap_3
X_4526_ _4526_/A0 _7284_/Q _4528_/B VGND VGND VPWR VPWR _7316_/D sky130_fd_sc_hd__mux2_2
XFILLER_104_315 VGND VGND VPWR VPWR sky130_fd_sc_hd__decap_3
XFILLER_116_175 VGND VGND VPWR VPWR sky130_fd_sc_hd__decap_3
XFILLER_116_197 VGND VGND VPWR VPWR sky130_fd_sc_hd__decap_3
X_7245_ _7372_/CLK _7245_/D _6525_/Y VGND VGND VPWR VPWR _7245_/Q sky130_fd_sc_hd__dfrtp_2
X_4457_ _4720_/A _4720_/B _4456_/X VGND VGND VPWR VPWR _4457_/X sky130_fd_sc_hd__o21a_2
XFILLER_49_39 VGND VGND VPWR VPWR sky130_fd_sc_hd__decap_3
X_7176_ _7368_/CLK _7176_/D _6456_/Y VGND VGND VPWR VPWR _7176_/Q sky130_fd_sc_hd__dfrtp_2
XFILLER_105_12 VGND VGND VPWR VPWR sky130_fd_sc_hd__decap_3
X_4388_ _7273_/Q _4437_/A2 _4385_/X _4387_/X VGND VGND VPWR VPWR _4388_/X sky130_fd_sc_hd__a211o_2
XFILLER_100_521 VGND VGND VPWR VPWR sky130_fd_sc_hd__fill_2
XFILLER_105_45 VGND VGND VPWR VPWR sky130_fd_sc_hd__decap_3
X_3339_ _3319_/X _5238_/B _3329_/Y _3339_/C1 VGND VGND VPWR VPWR _3469_/A sky130_fd_sc_hd__a211oi_2
XFILLER_100_587 VGND VGND VPWR VPWR sky130_fd_sc_hd__fill_1
XFILLER_105_78 VGND VGND VPWR VPWR sky130_fd_sc_hd__decap_3
XFILLER_105_89 VGND VGND VPWR VPWR sky130_fd_sc_hd__decap_3
XFILLER_39_671 VGND VGND VPWR VPWR sky130_fd_sc_hd__fill_1
XFILLER_73_405 VGND VGND VPWR VPWR sky130_fd_sc_hd__decap_3
XFILLER_73_416 VGND VGND VPWR VPWR sky130_fd_sc_hd__decap_3
XFILLER_39_682 VGND VGND VPWR VPWR sky130_fd_sc_hd__decap_3
XFILLER_66_490 VGND VGND VPWR VPWR sky130_fd_sc_hd__decap_3
XFILLER_73_438 VGND VGND VPWR VPWR sky130_fd_sc_hd__decap_3
XFILLER_73_449 VGND VGND VPWR VPWR sky130_fd_sc_hd__fill_1
X_5009_ _5009_/A _5009_/B VGND VGND VPWR VPWR _5010_/D sky130_fd_sc_hd__nor2_2
XFILLER_26_365 VGND VGND VPWR VPWR sky130_fd_sc_hd__decap_3
XFILLER_54_663 VGND VGND VPWR VPWR sky130_fd_sc_hd__decap_3
XFILLER_14_516 VGND VGND VPWR VPWR sky130_fd_sc_hd__decap_3
XFILLER_41_324 VGND VGND VPWR VPWR sky130_fd_sc_hd__decap_3
XFILLER_81_15 VGND VGND VPWR VPWR sky130_fd_sc_hd__decap_3
XFILLER_81_471 VGND VGND VPWR VPWR sky130_fd_sc_hd__decap_3
XFILLER_81_48 VGND VGND VPWR VPWR sky130_fd_sc_hd__decap_3
XTAP_TAPCELL_ROW_24_544 VGND VPWR sky130_fd_sc_hd__tapvpwrvgnd_1
XFILLER_14_53 VGND VGND VPWR VPWR sky130_fd_sc_hd__decap_3
XTAP_TAPCELL_ROW_52_875 VGND VPWR sky130_fd_sc_hd__tapvpwrvgnd_1
XFILLER_108_610 VGND VGND VPWR VPWR sky130_fd_sc_hd__decap_3
XFILLER_108_643 VGND VGND VPWR VPWR sky130_fd_sc_hd__fill_1
XFILLER_108_654 VGND VGND VPWR VPWR sky130_fd_sc_hd__decap_3
XFILLER_30_41 VGND VGND VPWR VPWR sky130_fd_sc_hd__decap_3
XFILLER_107_164 VGND VGND VPWR VPWR sky130_fd_sc_hd__decap_3
XFILLER_30_74 VGND VGND VPWR VPWR sky130_fd_sc_hd__decap_3
XFILLER_30_85 VGND VGND VPWR VPWR sky130_fd_sc_hd__fill_1
XFILLER_1_420 VGND VGND VPWR VPWR sky130_fd_sc_hd__decap_3
XFILLER_103_370 VGND VGND VPWR VPWR sky130_fd_sc_hd__decap_3
XFILLER_1_464 VGND VGND VPWR VPWR sky130_fd_sc_hd__decap_3
XFILLER_1_486 VGND VGND VPWR VPWR sky130_fd_sc_hd__fill_1
XFILLER_49_413 VGND VGND VPWR VPWR sky130_fd_sc_hd__decap_3
XFILLER_76_276 VGND VGND VPWR VPWR sky130_fd_sc_hd__decap_3
XFILLER_76_298 VGND VGND VPWR VPWR sky130_fd_sc_hd__fill_2
XPHY_EDGE_ROW_101_Right_101 VGND VGND VPWR VPWR sky130_fd_sc_hd__decap_3
XFILLER_45_641 VGND VGND VPWR VPWR sky130_fd_sc_hd__decap_3
XFILLER_55_60 VGND VGND VPWR VPWR sky130_fd_sc_hd__decap_3
XFILLER_91_268 VGND VGND VPWR VPWR sky130_fd_sc_hd__decap_3
XFILLER_45_685 VGND VGND VPWR VPWR sky130_fd_sc_hd__decap_3
XFILLER_60_622 VGND VGND VPWR VPWR sky130_fd_sc_hd__decap_3
XFILLER_32_346 VGND VGND VPWR VPWR sky130_fd_sc_hd__decap_3
XFILLER_60_666 VGND VGND VPWR VPWR sky130_fd_sc_hd__decap_3
XFILLER_58_3 VGND VGND VPWR VPWR sky130_fd_sc_hd__decap_3
X_5360_ _5360_/A0 _4470_/X _5360_/S VGND VGND VPWR VPWR _7151_/D sky130_fd_sc_hd__mux2_2
XFILLER_114_613 VGND VGND VPWR VPWR sky130_fd_sc_hd__decap_3
X_4311_ _4311_/A _4311_/B _4311_/C VGND VGND VPWR VPWR _4311_/X sky130_fd_sc_hd__or3_2
XFILLER_113_134 VGND VGND VPWR VPWR sky130_fd_sc_hd__decap_3
XFILLER_114_657 VGND VGND VPWR VPWR sky130_fd_sc_hd__decap_3
XFILLER_4_280 VGND VGND VPWR VPWR sky130_fd_sc_hd__fill_1
XFILLER_87_508 VGND VGND VPWR VPWR sky130_fd_sc_hd__fill_2
XFILLER_87_519 VGND VGND VPWR VPWR sky130_fd_sc_hd__decap_3
X_7030_ clkload9/A _7030_/D _6310_/Y VGND VGND VPWR VPWR _7030_/Q sky130_fd_sc_hd__dfrtp_2
XFILLER_113_167 VGND VGND VPWR VPWR sky130_fd_sc_hd__fill_1
XFILLER_113_178 VGND VGND VPWR VPWR sky130_fd_sc_hd__decap_3
X_4173_ _7072_/Q VGND VGND VPWR VPWR _4173_/Y sky130_fd_sc_hd__inv_2
XFILLER_28_608 VGND VGND VPWR VPWR sky130_fd_sc_hd__decap_3
XFILLER_55_449 VGND VGND VPWR VPWR sky130_fd_sc_hd__fill_1
XFILLER_82_235 VGND VGND VPWR VPWR sky130_fd_sc_hd__fill_2
XFILLER_95_596 VGND VGND VPWR VPWR sky130_fd_sc_hd__fill_1
XFILLER_51_611 VGND VGND VPWR VPWR sky130_fd_sc_hd__decap_3
XFILLER_23_324 VGND VGND VPWR VPWR sky130_fd_sc_hd__decap_3
XFILLER_35_184 VGND VGND VPWR VPWR sky130_fd_sc_hd__fill_1
XFILLER_50_132 VGND VGND VPWR VPWR sky130_fd_sc_hd__decap_3
XFILLER_51_644 VGND VGND VPWR VPWR sky130_fd_sc_hd__decap_3
Xplace460 _6979_/Q VGND VGND VPWR VPWR _5667_/A sky130_fd_sc_hd__buf_2
X_6814_ _6976_/CLK _6814_/D VGND VGND VPWR VPWR _6814_/Q sky130_fd_sc_hd__dfxtp_2
XFILLER_51_18 VGND VGND VPWR VPWR sky130_fd_sc_hd__decap_3
XFILLER_51_688 VGND VGND VPWR VPWR sky130_fd_sc_hd__decap_3
X_6745_ _6970_/CLK _6745_/D VGND VGND VPWR VPWR _6745_/Q sky130_fd_sc_hd__dfxtp_2
XTAP_TAPCELL_ROW_21_503 VGND VPWR sky130_fd_sc_hd__tapvpwrvgnd_1
X_6676_ _6684_/A VGND VGND VPWR VPWR _6676_/Y sky130_fd_sc_hd__inv_2
X_3888_ _6844_/Q _3892_/A2 _3888_/B1 _6839_/Q VGND VGND VPWR VPWR _3888_/X sky130_fd_sc_hd__a22o_2
XTAP_TAPCELL_ROW_98_1424 VGND VPWR sky130_fd_sc_hd__tapvpwrvgnd_1
XFILLER_104_112 VGND VGND VPWR VPWR sky130_fd_sc_hd__decap_3
XFILLER_105_613 VGND VGND VPWR VPWR sky130_fd_sc_hd__decap_3
XFILLER_105_635 VGND VGND VPWR VPWR sky130_fd_sc_hd__decap_3
XFILLER_2_206 VGND VGND VPWR VPWR sky130_fd_sc_hd__decap_3
X_4509_ _4509_/A1 _3398_/Y _4244_/X VGND VGND VPWR VPWR _7325_/D sky130_fd_sc_hd__a21o_2
XFILLER_104_134 VGND VGND VPWR VPWR sky130_fd_sc_hd__decap_3
XFILLER_105_668 VGND VGND VPWR VPWR sky130_fd_sc_hd__decap_3
XFILLER_105_679 VGND VGND VPWR VPWR sky130_fd_sc_hd__decap_3
X_7228_ _7390_/CLK _7228_/D _6508_/Y VGND VGND VPWR VPWR _7228_/Q sky130_fd_sc_hd__dfrtp_2
XFILLER_116_44 VGND VGND VPWR VPWR sky130_fd_sc_hd__decap_3
XFILLER_76_15 VGND VGND VPWR VPWR sky130_fd_sc_hd__fill_1
XFILLER_116_77 VGND VGND VPWR VPWR sky130_fd_sc_hd__decap_3
XFILLER_58_221 VGND VGND VPWR VPWR sky130_fd_sc_hd__decap_3
XFILLER_86_530 VGND VGND VPWR VPWR sky130_fd_sc_hd__fill_2
X_7159_ clkload4/A _7159_/D _6439_/Y VGND VGND VPWR VPWR _7159_/Q sky130_fd_sc_hd__dfrtp_2
XFILLER_18_107 VGND VGND VPWR VPWR sky130_fd_sc_hd__decap_3
XFILLER_76_59 VGND VGND VPWR VPWR sky130_fd_sc_hd__decap_3
XTAP_TAPCELL_ROW_29_603 VGND VPWR sky130_fd_sc_hd__tapvpwrvgnd_1
XFILLER_100_395 VGND VGND VPWR VPWR sky130_fd_sc_hd__decap_3
XFILLER_27_630 VGND VGND VPWR VPWR sky130_fd_sc_hd__decap_3
XFILLER_46_427 VGND VGND VPWR VPWR sky130_fd_sc_hd__decap_3
XFILLER_73_213 VGND VGND VPWR VPWR sky130_fd_sc_hd__decap_3
XTAP_TAPCELL_ROW_57_934 VGND VPWR sky130_fd_sc_hd__tapvpwrvgnd_1
XFILLER_73_257 VGND VGND VPWR VPWR sky130_fd_sc_hd__decap_3
Xclkbuf_leaf_38_clk clkbuf_3_6__f_clk/X VGND VGND VPWR VPWR _7387_/CLK sky130_fd_sc_hd__clkbuf_16
XTAP_TAPCELL_ROW_1_261 VGND VPWR sky130_fd_sc_hd__tapvpwrvgnd_1
XTAP_TAPCELL_ROW_107_1531 VGND VPWR sky130_fd_sc_hd__tapvpwrvgnd_1
XFILLER_92_47 VGND VGND VPWR VPWR sky130_fd_sc_hd__decap_3
XTAP_TAPCELL_ROW_37_691 VGND VPWR sky130_fd_sc_hd__tapvpwrvgnd_1
XFILLER_14_368 VGND VGND VPWR VPWR sky130_fd_sc_hd__decap_3
XFILLER_25_96 VGND VGND VPWR VPWR sky130_fd_sc_hd__decap_3
XFILLER_42_677 VGND VGND VPWR VPWR sky130_fd_sc_hd__decap_3
XFILLER_6_501 VGND VGND VPWR VPWR sky130_fd_sc_hd__decap_3
XFILLER_41_84 VGND VGND VPWR VPWR sky130_fd_sc_hd__decap_3
XFILLER_44_9 VGND VGND VPWR VPWR sky130_fd_sc_hd__decap_3
XTAP_TAPCELL_ROW_9_361 VGND VPWR sky130_fd_sc_hd__tapvpwrvgnd_1
XTAP_TAPCELL_ROW_71_1107 VGND VPWR sky130_fd_sc_hd__tapvpwrvgnd_1
XPHY_EDGE_ROW_102_Left_219 VGND VGND VPWR VPWR sky130_fd_sc_hd__decap_3
XFILLER_111_638 VGND VGND VPWR VPWR sky130_fd_sc_hd__decap_3
XFILLER_104_690 VGND VGND VPWR VPWR sky130_fd_sc_hd__fill_2
XFILLER_110_115 VGND VGND VPWR VPWR sky130_fd_sc_hd__decap_3
XFILLER_2_23 VGND VGND VPWR VPWR sky130_fd_sc_hd__decap_3
XFILLER_89_390 VGND VGND VPWR VPWR sky130_fd_sc_hd__fill_2
XFILLER_110_159 VGND VGND VPWR VPWR sky130_fd_sc_hd__decap_3
XFILLER_2_56 VGND VGND VPWR VPWR sky130_fd_sc_hd__decap_3
XFILLER_49_298 VGND VGND VPWR VPWR sky130_fd_sc_hd__decap_3
XFILLER_66_81 VGND VGND VPWR VPWR sky130_fd_sc_hd__decap_3
XFILLER_92_522 VGND VGND VPWR VPWR sky130_fd_sc_hd__decap_3
XFILLER_92_533 VGND VGND VPWR VPWR sky130_fd_sc_hd__decap_3
XFILLER_52_408 VGND VGND VPWR VPWR sky130_fd_sc_hd__fill_1
XFILLER_92_566 VGND VGND VPWR VPWR sky130_fd_sc_hd__fill_1
Xclkbuf_leaf_29_clk clkbuf_3_2__f_clk/X VGND VGND VPWR VPWR _6909_/CLK sky130_fd_sc_hd__clkbuf_16
XFILLER_17_151 VGND VGND VPWR VPWR sky130_fd_sc_hd__decap_3
XFILLER_64_279 VGND VGND VPWR VPWR sky130_fd_sc_hd__fill_1
XFILLER_60_441 VGND VGND VPWR VPWR sky130_fd_sc_hd__fill_1
X_4860_ _4687_/B _4859_/Y _5570_/A2 VGND VGND VPWR VPWR _4860_/Y sky130_fd_sc_hd__o21ai_2
XTAP_TAPCELL_ROW_82_1236 VGND VPWR sky130_fd_sc_hd__tapvpwrvgnd_1
XPHY_EDGE_ROW_111_Left_228 VGND VGND VPWR VPWR sky130_fd_sc_hd__decap_3
XFILLER_60_463 VGND VGND VPWR VPWR sky130_fd_sc_hd__decap_3
XFILLER_82_80 VGND VGND VPWR VPWR sky130_fd_sc_hd__decap_3
X_3811_ _3682_/A _3808_/X _3810_/X _3741_/X VGND VGND VPWR VPWR _3811_/X sky130_fd_sc_hd__a22o_2
XFILLER_20_338 VGND VGND VPWR VPWR sky130_fd_sc_hd__decap_3
X_6530_ _6600_/A VGND VGND VPWR VPWR _6530_/Y sky130_fd_sc_hd__inv_2
X_4791_ _4791_/A1 _5664_/A _3697_/Y _3509_/B VGND VGND VPWR VPWR _4791_/Y sky130_fd_sc_hd__a211oi_2
XFILLER_13_390 VGND VGND VPWR VPWR sky130_fd_sc_hd__fill_2
X_3742_ _6833_/Q _3893_/B1 _3892_/B1 _6843_/Q VGND VGND VPWR VPWR _3742_/X sky130_fd_sc_hd__a22o_2
X_6461_ _6651_/A VGND VGND VPWR VPWR _6461_/Y sky130_fd_sc_hd__inv_2
X_3673_ _6856_/Q _6864_/Q _6904_/Q _6912_/Q _3991_/B _3665_/B VGND VGND VPWR VPWR
+ _3673_/X sky130_fd_sc_hd__mux4_2
X_6392_ _6483_/A VGND VGND VPWR VPWR _6392_/Y sky130_fd_sc_hd__inv_2
XFILLER_114_421 VGND VGND VPWR VPWR sky130_fd_sc_hd__decap_3
XTAP_TAPCELL_ROW_93_1365 VGND VPWR sky130_fd_sc_hd__tapvpwrvgnd_1
XFILLER_102_627 VGND VGND VPWR VPWR sky130_fd_sc_hd__decap_3
X_5274_ _5274_/A0 _5079_/X _5274_/S VGND VGND VPWR VPWR _7193_/D sky130_fd_sc_hd__mux2_2
XFILLER_101_126 VGND VGND VPWR VPWR sky130_fd_sc_hd__decap_3
XFILLER_68_541 VGND VGND VPWR VPWR sky130_fd_sc_hd__fill_2
X_7013_ clkload8/A _7013_/D _6293_/Y VGND VGND VPWR VPWR _7013_/Q sky130_fd_sc_hd__dfrtp_2
X_4225_ _4371_/A _4371_/B _4224_/C VGND VGND VPWR VPWR _4627_/A sky130_fd_sc_hd__a21oi_2
XFILLER_101_159 VGND VGND VPWR VPWR sky130_fd_sc_hd__decap_3
XFILLER_110_660 VGND VGND VPWR VPWR sky130_fd_sc_hd__decap_3
XFILLER_68_574 VGND VGND VPWR VPWR sky130_fd_sc_hd__fill_1
X_4156_ _4157_/A _4205_/C VGND VGND VPWR VPWR _4158_/A sky130_fd_sc_hd__or2_2
XFILLER_28_427 VGND VGND VPWR VPWR sky130_fd_sc_hd__decap_3
XFILLER_46_29 VGND VGND VPWR VPWR sky130_fd_sc_hd__fill_1
XFILLER_95_393 VGND VGND VPWR VPWR sky130_fd_sc_hd__decap_3
XFILLER_55_257 VGND VGND VPWR VPWR sky130_fd_sc_hd__decap_3
X_4087_ _7078_/Q _4432_/A2 _4432_/B1 _4086_/X VGND VGND VPWR VPWR _4095_/A sky130_fd_sc_hd__o211ai_2
XTAP_TAPCELL_ROW_54_904 VGND VPWR sky130_fd_sc_hd__tapvpwrvgnd_1
XFILLER_102_24 VGND VGND VPWR VPWR sky130_fd_sc_hd__decap_3
XFILLER_102_46 VGND VGND VPWR VPWR sky130_fd_sc_hd__decap_3
XFILLER_36_460 VGND VGND VPWR VPWR sky130_fd_sc_hd__decap_3
XFILLER_70_249 VGND VGND VPWR VPWR sky130_fd_sc_hd__decap_3
XFILLER_23_165 VGND VGND VPWR VPWR sky130_fd_sc_hd__decap_3
XFILLER_24_688 VGND VGND VPWR VPWR sky130_fd_sc_hd__decap_3
Xplace290 _3651_/Y VGND VGND VPWR VPWR _3886_/B1 sky130_fd_sc_hd__buf_2
XTAP_TAPCELL_ROW_34_661 VGND VPWR sky130_fd_sc_hd__tapvpwrvgnd_1
XFILLER_23_187 VGND VGND VPWR VPWR sky130_fd_sc_hd__decap_3
X_4989_ _5032_/A _5032_/B VGND VGND VPWR VPWR _4989_/X sky130_fd_sc_hd__or2b_2
XTAP_TAPCELL_ROW_62_992 VGND VPWR sky130_fd_sc_hd__tapvpwrvgnd_1
XTAP_TAPCELL_ROW_102_1472 VGND VPWR sky130_fd_sc_hd__tapvpwrvgnd_1
X_6728_ _6978_/CLK _6728_/D VGND VGND VPWR VPWR _6728_/Q sky130_fd_sc_hd__dfxtp_2
X_6659_ _6660_/A VGND VGND VPWR VPWR _6659_/Y sky130_fd_sc_hd__inv_2
XFILLER_11_21 VGND VGND VPWR VPWR sky130_fd_sc_hd__decap_3
XFILLER_11_54 VGND VGND VPWR VPWR sky130_fd_sc_hd__fill_2
XFILLER_105_443 VGND VGND VPWR VPWR sky130_fd_sc_hd__decap_3
XFILLER_11_87 VGND VGND VPWR VPWR sky130_fd_sc_hd__decap_3
XFILLER_87_47 VGND VGND VPWR VPWR sky130_fd_sc_hd__decap_3
XFILLER_87_69 VGND VGND VPWR VPWR sky130_fd_sc_hd__decap_3
XTAP_TAPCELL_ROW_6_320 VGND VPWR sky130_fd_sc_hd__tapvpwrvgnd_1
XFILLER_74_500 VGND VGND VPWR VPWR sky130_fd_sc_hd__decap_3
XFILLER_101_671 VGND VGND VPWR VPWR sky130_fd_sc_hd__fill_1
XFILLER_101_682 VGND VGND VPWR VPWR sky130_fd_sc_hd__decap_3
XFILLER_46_224 VGND VGND VPWR VPWR sky130_fd_sc_hd__decap_3
XFILLER_59_596 VGND VGND VPWR VPWR sky130_fd_sc_hd__decap_3
XFILLER_74_533 VGND VGND VPWR VPWR sky130_fd_sc_hd__fill_1
XFILLER_19_449 VGND VGND VPWR VPWR sky130_fd_sc_hd__decap_3
XFILLER_34_419 VGND VGND VPWR VPWR sky130_fd_sc_hd__fill_1
XFILLER_46_268 VGND VGND VPWR VPWR sky130_fd_sc_hd__fill_1
XFILLER_61_205 VGND VGND VPWR VPWR sky130_fd_sc_hd__decap_3
XFILLER_36_95 VGND VGND VPWR VPWR sky130_fd_sc_hd__decap_3
XFILLER_54_290 VGND VGND VPWR VPWR sky130_fd_sc_hd__decap_3
XFILLER_61_249 VGND VGND VPWR VPWR sky130_fd_sc_hd__decap_3
XFILLER_42_463 VGND VGND VPWR VPWR sky130_fd_sc_hd__decap_3
XFILLER_52_61 VGND VGND VPWR VPWR sky130_fd_sc_hd__fill_1
XFILLER_52_83 VGND VGND VPWR VPWR sky130_fd_sc_hd__fill_1
XFILLER_6_342 VGND VGND VPWR VPWR sky130_fd_sc_hd__decap_3
XTAP_TAPCELL_ROW_12_399 VGND VPWR sky130_fd_sc_hd__tapvpwrvgnd_1
XFILLER_108_292 VGND VGND VPWR VPWR sky130_fd_sc_hd__decap_3
XFILLER_42_6 VGND VGND VPWR VPWR sky130_fd_sc_hd__decap_3
XFILLER_2_592 VGND VGND VPWR VPWR sky130_fd_sc_hd__decap_3
XFILLER_96_124 VGND VGND VPWR VPWR sky130_fd_sc_hd__decap_3
XFILLER_97_647 VGND VGND VPWR VPWR sky130_fd_sc_hd__decap_3
XFILLER_65_533 VGND VGND VPWR VPWR sky130_fd_sc_hd__decap_3
XFILLER_77_393 VGND VGND VPWR VPWR sky130_fd_sc_hd__decap_3
XFILLER_18_460 VGND VGND VPWR VPWR sky130_fd_sc_hd__decap_3
XFILLER_25_408 VGND VGND VPWR VPWR sky130_fd_sc_hd__decap_3
XFILLER_65_588 VGND VGND VPWR VPWR sky130_fd_sc_hd__decap_3
XFILLER_92_363 VGND VGND VPWR VPWR sky130_fd_sc_hd__fill_1
XFILLER_45_290 VGND VGND VPWR VPWR sky130_fd_sc_hd__decap_3
XFILLER_52_249 VGND VGND VPWR VPWR sky130_fd_sc_hd__decap_3
X_4912_ _4912_/A _4912_/B VGND VGND VPWR VPWR _6997_/D sky130_fd_sc_hd__nor2_2
XFILLER_20_102 VGND VGND VPWR VPWR sky130_fd_sc_hd__decap_3
XFILLER_33_474 VGND VGND VPWR VPWR sky130_fd_sc_hd__decap_3
XFILLER_60_271 VGND VGND VPWR VPWR sky130_fd_sc_hd__decap_3
X_4843_ _4111_/B _4842_/X _4633_/A VGND VGND VPWR VPWR _4843_/Y sky130_fd_sc_hd__a21oi_2
XTAP_TAPCELL_ROW_31_620 VGND VPWR sky130_fd_sc_hd__tapvpwrvgnd_1
XFILLER_21_658 VGND VGND VPWR VPWR sky130_fd_sc_hd__decap_3
X_4774_ _7004_/Q _4801_/A VGND VGND VPWR VPWR _4775_/B sky130_fd_sc_hd__nor2_2
X_6513_ _6578_/A VGND VGND VPWR VPWR _6513_/Y sky130_fd_sc_hd__inv_2
X_3725_ _3735_/A _3741_/B _3733_/C VGND VGND VPWR VPWR _3725_/X sky130_fd_sc_hd__and3_2
Xclkbuf_leaf_9_clk clkbuf_leaf_9_clk/A VGND VGND VPWR VPWR _7397_/CLK sky130_fd_sc_hd__clkbuf_16
X_6444_ _6604_/A VGND VGND VPWR VPWR _6444_/Y sky130_fd_sc_hd__inv_2
X_3656_ _3991_/B _3665_/B VGND VGND VPWR VPWR _3656_/Y sky130_fd_sc_hd__nor2_2
X_6375_ _6568_/A VGND VGND VPWR VPWR _6375_/Y sky130_fd_sc_hd__inv_2
X_3587_ _3599_/A _3600_/A VGND VGND VPWR VPWR _4292_/B sky130_fd_sc_hd__or2_4
XFILLER_0_529 VGND VGND VPWR VPWR sky130_fd_sc_hd__decap_3
XFILLER_114_251 VGND VGND VPWR VPWR sky130_fd_sc_hd__fill_1
XFILLER_114_262 VGND VGND VPWR VPWR sky130_fd_sc_hd__decap_3
XFILLER_88_614 VGND VGND VPWR VPWR sky130_fd_sc_hd__decap_3
XFILLER_102_424 VGND VGND VPWR VPWR sky130_fd_sc_hd__decap_3
XFILLER_114_295 VGND VGND VPWR VPWR sky130_fd_sc_hd__decap_3
XFILLER_57_17 VGND VGND VPWR VPWR sky130_fd_sc_hd__decap_3
XFILLER_87_113 VGND VGND VPWR VPWR sky130_fd_sc_hd__decap_3
XFILLER_102_457 VGND VGND VPWR VPWR sky130_fd_sc_hd__decap_3
XFILLER_87_146 VGND VGND VPWR VPWR sky130_fd_sc_hd__decap_3
XFILLER_88_669 VGND VGND VPWR VPWR sky130_fd_sc_hd__decap_3
X_4208_ _4886_/A _4208_/B VGND VGND VPWR VPWR _4903_/A sky130_fd_sc_hd__nor2_2
XFILLER_113_12 VGND VGND VPWR VPWR sky130_fd_sc_hd__decap_3
XFILLER_68_371 VGND VGND VPWR VPWR sky130_fd_sc_hd__decap_3
X_5188_ _5188_/A _5205_/B VGND VGND VPWR VPWR _7234_/D sky130_fd_sc_hd__and2_2
XTAP_TAPCELL_ROW_39_720 VGND VPWR sky130_fd_sc_hd__tapvpwrvgnd_1
XFILLER_113_45 VGND VGND VPWR VPWR sky130_fd_sc_hd__decap_3
XFILLER_28_246 VGND VGND VPWR VPWR sky130_fd_sc_hd__decap_3
XFILLER_68_393 VGND VGND VPWR VPWR sky130_fd_sc_hd__decap_3
X_4139_ _4207_/A _4642_/B VGND VGND VPWR VPWR _4886_/A sky130_fd_sc_hd__nor2_2
XFILLER_113_78 VGND VGND VPWR VPWR sky130_fd_sc_hd__decap_3
XFILLER_28_268 VGND VGND VPWR VPWR sky130_fd_sc_hd__decap_3
XFILLER_71_558 VGND VGND VPWR VPWR sky130_fd_sc_hd__fill_2
XFILLER_73_49 VGND VGND VPWR VPWR sky130_fd_sc_hd__decap_3
XTAP_TAPCELL_ROW_104_1501 VGND VPWR sky130_fd_sc_hd__tapvpwrvgnd_1
XFILLER_11_102 VGND VGND VPWR VPWR sky130_fd_sc_hd__decap_3
XFILLER_11_113 VGND VGND VPWR VPWR sky130_fd_sc_hd__decap_3
XFILLER_12_625 VGND VGND VPWR VPWR sky130_fd_sc_hd__fill_2
XFILLER_8_607 VGND VGND VPWR VPWR sky130_fd_sc_hd__decap_3
XFILLER_11_179 VGND VGND VPWR VPWR sky130_fd_sc_hd__decap_3
XFILLER_22_42 VGND VGND VPWR VPWR sky130_fd_sc_hd__decap_3
XFILLER_7_128 VGND VGND VPWR VPWR sky130_fd_sc_hd__decap_3
XFILLER_22_64 VGND VGND VPWR VPWR sky130_fd_sc_hd__decap_3
XTAP_TAPCELL_ROW_115_1630 VGND VPWR sky130_fd_sc_hd__tapvpwrvgnd_1
XFILLER_98_68 VGND VGND VPWR VPWR sky130_fd_sc_hd__decap_3
XFILLER_3_378 VGND VGND VPWR VPWR sky130_fd_sc_hd__decap_3
XFILLER_79_614 VGND VGND VPWR VPWR sky130_fd_sc_hd__fill_2
XFILLER_105_284 VGND VGND VPWR VPWR sky130_fd_sc_hd__decap_3
XFILLER_78_113 VGND VGND VPWR VPWR sky130_fd_sc_hd__decap_3
XFILLER_79_647 VGND VGND VPWR VPWR sky130_fd_sc_hd__decap_3
XFILLER_78_168 VGND VGND VPWR VPWR sky130_fd_sc_hd__decap_3
XFILLER_94_606 VGND VGND VPWR VPWR sky130_fd_sc_hd__decap_3
XFILLER_87_691 VGND VGND VPWR VPWR sky130_fd_sc_hd__fill_1
XFILLER_93_116 VGND VGND VPWR VPWR sky130_fd_sc_hd__decap_3
XFILLER_94_639 VGND VGND VPWR VPWR sky130_fd_sc_hd__decap_3
XFILLER_47_72 VGND VGND VPWR VPWR sky130_fd_sc_hd__decap_3
XFILLER_47_83 VGND VGND VPWR VPWR sky130_fd_sc_hd__decap_3
XFILLER_59_393 VGND VGND VPWR VPWR sky130_fd_sc_hd__decap_3
XFILLER_74_330 VGND VGND VPWR VPWR sky130_fd_sc_hd__decap_3
XFILLER_93_138 VGND VGND VPWR VPWR sky130_fd_sc_hd__decap_3
XFILLER_19_257 VGND VGND VPWR VPWR sky130_fd_sc_hd__fill_2
XFILLER_19_268 VGND VGND VPWR VPWR sky130_fd_sc_hd__decap_3
XTAP_TAPCELL_ROW_66_1039 VGND VPWR sky130_fd_sc_hd__tapvpwrvgnd_1
XFILLER_15_430 VGND VGND VPWR VPWR sky130_fd_sc_hd__decap_3
XFILLER_27_290 VGND VGND VPWR VPWR sky130_fd_sc_hd__decap_3
XTAP_TAPCELL_ROW_17_458 VGND VPWR sky130_fd_sc_hd__tapvpwrvgnd_1
XFILLER_42_271 VGND VGND VPWR VPWR sky130_fd_sc_hd__fill_2
Xclkbuf_3_4__f_clk clkbuf_0_clk/X VGND VGND VPWR VPWR clkbuf_leaf_4_clk/A sky130_fd_sc_hd__clkbuf_16
XTAP_TAPCELL_ROW_45_789 VGND VPWR sky130_fd_sc_hd__tapvpwrvgnd_1
XFILLER_42_293 VGND VGND VPWR VPWR sky130_fd_sc_hd__decap_3
XFILLER_8_11 VGND VGND VPWR VPWR sky130_fd_sc_hd__decap_3
XFILLER_30_488 VGND VGND VPWR VPWR sky130_fd_sc_hd__decap_3
XFILLER_8_44 VGND VGND VPWR VPWR sky130_fd_sc_hd__decap_3
XFILLER_11_691 VGND VGND VPWR VPWR sky130_fd_sc_hd__fill_1
XFILLER_7_651 VGND VGND VPWR VPWR sky130_fd_sc_hd__decap_3
XFILLER_8_77 VGND VGND VPWR VPWR sky130_fd_sc_hd__decap_3
XFILLER_8_88 VGND VGND VPWR VPWR sky130_fd_sc_hd__decap_3
Xwire560 _4619_/Y VGND VGND VPWR VPWR wire560/X sky130_fd_sc_hd__clkdlybuf4s25_1
X_3510_ _3330_/Y _3383_/B _3442_/B _3403_/A VGND VGND VPWR VPWR _3510_/X sky130_fd_sc_hd__a2bb2o_2
XFILLER_116_516 VGND VGND VPWR VPWR sky130_fd_sc_hd__decap_3
XFILLER_6_150 VGND VGND VPWR VPWR sky130_fd_sc_hd__decap_3
XFILLER_7_673 VGND VGND VPWR VPWR sky130_fd_sc_hd__decap_3
Xhold607 _6935_/Q VGND VGND VPWR VPWR _6935_/D sky130_fd_sc_hd__dlygate4sd3_1
Xhold618 _6798_/Q VGND VGND VPWR VPWR _6798_/D sky130_fd_sc_hd__dlygate4sd3_1
Xwire571 _6982_/D VGND VGND VPWR VPWR wire571/X sky130_fd_sc_hd__clkbuf_2
Xhold629 _6883_/Q VGND VGND VPWR VPWR _6883_/D sky130_fd_sc_hd__dlygate4sd3_1
X_3441_ _7058_/Q _3577_/B _4460_/A _3440_/X VGND VGND VPWR VPWR _3544_/A sky130_fd_sc_hd__o211ai_2
XTAP_TAPCELL_ROW_77_1179 VGND VPWR sky130_fd_sc_hd__tapvpwrvgnd_1
XFILLER_40_3 VGND VGND VPWR VPWR sky130_fd_sc_hd__decap_3
XFILLER_69_102 VGND VGND VPWR VPWR sky130_fd_sc_hd__decap_3
XFILLER_69_113 VGND VGND VPWR VPWR sky130_fd_sc_hd__decap_3
XFILLER_69_124 VGND VGND VPWR VPWR sky130_fd_sc_hd__decap_3
X_5111_ _3610_/A _3603_/Y _4292_/C _3548_/X VGND VGND VPWR VPWR _5111_/X sky130_fd_sc_hd__a31o_2
XTAP_TAPCELL_ROW_90_1335 VGND VPWR sky130_fd_sc_hd__tapvpwrvgnd_1
XFILLER_85_617 VGND VGND VPWR VPWR sky130_fd_sc_hd__decap_3
XFILLER_97_455 VGND VGND VPWR VPWR sky130_fd_sc_hd__decap_3
XFILLER_57_319 VGND VGND VPWR VPWR sky130_fd_sc_hd__decap_3
XFILLER_84_105 VGND VGND VPWR VPWR sky130_fd_sc_hd__decap_3
XFILLER_97_499 VGND VGND VPWR VPWR sky130_fd_sc_hd__decap_3
XFILLER_38_533 VGND VGND VPWR VPWR sky130_fd_sc_hd__decap_3
XFILLER_84_138 VGND VGND VPWR VPWR sky130_fd_sc_hd__fill_2
XFILLER_93_650 VGND VGND VPWR VPWR sky130_fd_sc_hd__decap_3
XFILLER_25_205 VGND VGND VPWR VPWR sky130_fd_sc_hd__decap_3
XFILLER_65_363 VGND VGND VPWR VPWR sky130_fd_sc_hd__decap_3
XFILLER_25_216 VGND VGND VPWR VPWR sky130_fd_sc_hd__decap_3
XFILLER_53_558 VGND VGND VPWR VPWR sky130_fd_sc_hd__fill_2
XFILLER_65_396 VGND VGND VPWR VPWR sky130_fd_sc_hd__decap_3
XFILLER_92_182 VGND VGND VPWR VPWR sky130_fd_sc_hd__decap_3
X_6993_ _7398_/CLK _6993_/D _6273_/Y VGND VGND VPWR VPWR _6993_/Q sky130_fd_sc_hd__dfrtp_2
XFILLER_33_260 VGND VGND VPWR VPWR sky130_fd_sc_hd__decap_3
XFILLER_21_455 VGND VGND VPWR VPWR sky130_fd_sc_hd__decap_3
X_4826_ _4826_/A _4826_/B VGND VGND VPWR VPWR _7001_/D sky130_fd_sc_hd__nor2_2
X_4757_ _4757_/A _4665_/X VGND VGND VPWR VPWR _4759_/A sky130_fd_sc_hd__or2b_2
XFILLER_107_505 VGND VGND VPWR VPWR sky130_fd_sc_hd__decap_3
XFILLER_111_9 VGND VGND VPWR VPWR sky130_fd_sc_hd__decap_3
XFILLER_4_109 VGND VGND VPWR VPWR sky130_fd_sc_hd__decap_3
X_4688_ _7001_/Q _7002_/Q _4687_/B _5633_/B VGND VGND VPWR VPWR _4688_/X sky130_fd_sc_hd__a31o_2
X_3708_ _6801_/Q _3759_/A2 _3767_/A2 _6711_/Q _3707_/X VGND VGND VPWR VPWR _3708_/X
+ sky130_fd_sc_hd__a221o_2
XFILLER_108_12 VGND VGND VPWR VPWR sky130_fd_sc_hd__decap_3
X_6427_ _6558_/A VGND VGND VPWR VPWR _6427_/Y sky130_fd_sc_hd__inv_2
X_3639_ _3636_/Y _3548_/X _3505_/X _5020_/A _3638_/X VGND VGND VPWR VPWR _3639_/X
+ sky130_fd_sc_hd__o221a_2
XFILLER_108_56 VGND VGND VPWR VPWR sky130_fd_sc_hd__decap_3
X_6358_ _6385_/A VGND VGND VPWR VPWR _6358_/Y sky130_fd_sc_hd__inv_2
XFILLER_0_337 VGND VGND VPWR VPWR sky130_fd_sc_hd__decap_3
XFILLER_115_582 VGND VGND VPWR VPWR sky130_fd_sc_hd__decap_3
XFILLER_68_38 VGND VGND VPWR VPWR sky130_fd_sc_hd__decap_3
XFILLER_88_433 VGND VGND VPWR VPWR sky130_fd_sc_hd__decap_3
XFILLER_0_359 VGND VGND VPWR VPWR sky130_fd_sc_hd__decap_3
XFILLER_88_477 VGND VGND VPWR VPWR sky130_fd_sc_hd__fill_1
X_6289_ _6388_/A VGND VGND VPWR VPWR _6289_/Y sky130_fd_sc_hd__inv_2
XFILLER_102_265 VGND VGND VPWR VPWR sky130_fd_sc_hd__decap_3
XFILLER_76_639 VGND VGND VPWR VPWR sky130_fd_sc_hd__decap_3
XTAP_TAPCELL_ROW_110_1571 VGND VPWR sky130_fd_sc_hd__tapvpwrvgnd_1
XFILLER_102_298 VGND VGND VPWR VPWR sky130_fd_sc_hd__decap_3
XFILLER_29_544 VGND VGND VPWR VPWR sky130_fd_sc_hd__decap_3
XFILLER_68_190 VGND VGND VPWR VPWR sky130_fd_sc_hd__decap_3
XFILLER_69_691 VGND VGND VPWR VPWR sky130_fd_sc_hd__fill_1
XFILLER_84_15 VGND VGND VPWR VPWR sky130_fd_sc_hd__decap_3
XFILLER_84_672 VGND VGND VPWR VPWR sky130_fd_sc_hd__decap_3
XFILLER_16_238 VGND VGND VPWR VPWR sky130_fd_sc_hd__decap_3
XFILLER_71_322 VGND VGND VPWR VPWR sky130_fd_sc_hd__decap_3
XFILLER_17_75 VGND VGND VPWR VPWR sky130_fd_sc_hd__decap_3
XFILLER_31_208 VGND VGND VPWR VPWR sky130_fd_sc_hd__decap_3
XFILLER_24_271 VGND VGND VPWR VPWR sky130_fd_sc_hd__decap_3
XFILLER_71_399 VGND VGND VPWR VPWR sky130_fd_sc_hd__decap_3
XTAP_TAPCELL_ROW_14_417 VGND VPWR sky130_fd_sc_hd__tapvpwrvgnd_1
XFILLER_12_433 VGND VGND VPWR VPWR sky130_fd_sc_hd__fill_2
XTAP_TAPCELL_ROW_42_759 VGND VPWR sky130_fd_sc_hd__tapvpwrvgnd_1
XFILLER_12_477 VGND VGND VPWR VPWR sky130_fd_sc_hd__decap_3
XFILLER_33_63 VGND VGND VPWR VPWR sky130_fd_sc_hd__fill_1
XFILLER_8_448 VGND VGND VPWR VPWR sky130_fd_sc_hd__decap_3
XFILLER_4_632 VGND VGND VPWR VPWR sky130_fd_sc_hd__decap_3
XFILLER_113_508 VGND VGND VPWR VPWR sky130_fd_sc_hd__fill_2
XFILLER_3_131 VGND VGND VPWR VPWR sky130_fd_sc_hd__decap_3
XFILLER_4_654 VGND VGND VPWR VPWR sky130_fd_sc_hd__decap_3
XFILLER_4_687 VGND VGND VPWR VPWR sky130_fd_sc_hd__decap_3
XFILLER_79_433 VGND VGND VPWR VPWR sky130_fd_sc_hd__decap_3
XFILLER_39_308 VGND VGND VPWR VPWR sky130_fd_sc_hd__decap_3
XFILLER_67_606 VGND VGND VPWR VPWR sky130_fd_sc_hd__decap_3
XFILLER_67_617 VGND VGND VPWR VPWR sky130_fd_sc_hd__decap_3
XFILLER_66_105 VGND VGND VPWR VPWR sky130_fd_sc_hd__decap_3
XFILLER_59_190 VGND VGND VPWR VPWR sky130_fd_sc_hd__decap_3
XFILLER_66_138 VGND VGND VPWR VPWR sky130_fd_sc_hd__fill_2
XFILLER_35_503 VGND VGND VPWR VPWR sky130_fd_sc_hd__fill_1
XFILLER_81_119 VGND VGND VPWR VPWR sky130_fd_sc_hd__decap_3
XFILLER_47_396 VGND VGND VPWR VPWR sky130_fd_sc_hd__decap_3
XFILLER_62_322 VGND VGND VPWR VPWR sky130_fd_sc_hd__decap_3
XFILLER_74_160 VGND VGND VPWR VPWR sky130_fd_sc_hd__decap_3
XFILLER_74_182 VGND VGND VPWR VPWR sky130_fd_sc_hd__decap_3
XFILLER_74_193 VGND VGND VPWR VPWR sky130_fd_sc_hd__decap_3
XFILLER_90_631 VGND VGND VPWR VPWR sky130_fd_sc_hd__decap_3
XFILLER_35_558 VGND VGND VPWR VPWR sky130_fd_sc_hd__fill_2
XFILLER_90_675 VGND VGND VPWR VPWR sky130_fd_sc_hd__decap_3
XFILLER_15_260 VGND VGND VPWR VPWR sky130_fd_sc_hd__decap_3
XFILLER_50_528 VGND VGND VPWR VPWR sky130_fd_sc_hd__decap_3
XFILLER_62_399 VGND VGND VPWR VPWR sky130_fd_sc_hd__decap_3
XFILLER_15_293 VGND VGND VPWR VPWR sky130_fd_sc_hd__decap_3
X_5660_ _5660_/A _5660_/B _5660_/C _5660_/D VGND VGND VPWR VPWR _5661_/D sky130_fd_sc_hd__and4_2
XFILLER_88_3 VGND VGND VPWR VPWR sky130_fd_sc_hd__decap_3
XFILLER_90_91 VGND VGND VPWR VPWR sky130_fd_sc_hd__decap_3
X_4611_ _4611_/A VGND VGND VPWR VPWR _4611_/Y sky130_fd_sc_hd__inv_2
X_5591_ _5591_/A _5595_/B VGND VGND VPWR VPWR _7032_/D sky130_fd_sc_hd__or2_2
X_7330_ _7397_/CLK _7330_/D _6610_/Y VGND VGND VPWR VPWR _7330_/Q sky130_fd_sc_hd__dfrtp_2
X_4542_ _4542_/A _4571_/B VGND VGND VPWR VPWR _7309_/D sky130_fd_sc_hd__and2_2
XFILLER_116_324 VGND VGND VPWR VPWR sky130_fd_sc_hd__decap_3
X_7261_ _7294_/CLK _7261_/D _6541_/Y VGND VGND VPWR VPWR _7261_/Q sky130_fd_sc_hd__dfrtp_2
XFILLER_116_368 VGND VGND VPWR VPWR sky130_fd_sc_hd__decap_3
X_3424_ _3398_/Y _3419_/Y _3424_/S VGND VGND VPWR VPWR _3590_/C sky130_fd_sc_hd__mux2_4
X_7192_ _7384_/CLK _7192_/D _6472_/Y VGND VGND VPWR VPWR _7192_/Q sky130_fd_sc_hd__dfrtp_2
XPHY_EDGE_ROW_115_Right_115 VGND VGND VPWR VPWR sky130_fd_sc_hd__decap_3
X_3355_ _3371_/A _5668_/A _3519_/B VGND VGND VPWR VPWR _3355_/Y sky130_fd_sc_hd__o21ai_2
XFILLER_112_563 VGND VGND VPWR VPWR sky130_fd_sc_hd__decap_3
XFILLER_58_628 VGND VGND VPWR VPWR sky130_fd_sc_hd__decap_3
XFILLER_85_425 VGND VGND VPWR VPWR sky130_fd_sc_hd__decap_3
XFILLER_97_263 VGND VGND VPWR VPWR sky130_fd_sc_hd__decap_3
Xhold1104 _7284_/Q VGND VGND VPWR VPWR _4593_/A sky130_fd_sc_hd__dlygate4sd3_1
Xhold1115 _7261_/Q VGND VGND VPWR VPWR _5012_/A0 sky130_fd_sc_hd__dlygate4sd3_1
XFILLER_85_447 VGND VGND VPWR VPWR sky130_fd_sc_hd__fill_1
XFILLER_85_458 VGND VGND VPWR VPWR sky130_fd_sc_hd__decap_3
XFILLER_97_296 VGND VGND VPWR VPWR sky130_fd_sc_hd__decap_3
Xhold1126 _7250_/Q VGND VGND VPWR VPWR _5140_/A0 sky130_fd_sc_hd__dlygate4sd3_1
Xhold1137 _7012_/Q VGND VGND VPWR VPWR _5632_/A sky130_fd_sc_hd__dlygate4sd3_1
Xhold1148 _7294_/Q VGND VGND VPWR VPWR _4573_/A sky130_fd_sc_hd__dlygate4sd3_1
X_5025_ _6989_/Q _5044_/A _6990_/Q VGND VGND VPWR VPWR _5026_/B sky130_fd_sc_hd__a21oi_2
XFILLER_38_363 VGND VGND VPWR VPWR sky130_fd_sc_hd__fill_1
XFILLER_66_672 VGND VGND VPWR VPWR sky130_fd_sc_hd__decap_3
Xhold1159 _7220_/Q VGND VGND VPWR VPWR _5217_/A sky130_fd_sc_hd__dlygate4sd3_1
XFILLER_38_385 VGND VGND VPWR VPWR sky130_fd_sc_hd__decap_3
XFILLER_53_322 VGND VGND VPWR VPWR sky130_fd_sc_hd__decap_3
XFILLER_54_18 VGND VGND VPWR VPWR sky130_fd_sc_hd__decap_3
XFILLER_54_29 VGND VGND VPWR VPWR sky130_fd_sc_hd__fill_2
XFILLER_81_620 VGND VGND VPWR VPWR sky130_fd_sc_hd__decap_3
XFILLER_65_193 VGND VGND VPWR VPWR sky130_fd_sc_hd__decap_3
XFILLER_80_141 VGND VGND VPWR VPWR sky130_fd_sc_hd__decap_3
XFILLER_81_653 VGND VGND VPWR VPWR sky130_fd_sc_hd__decap_3
X_6976_ _6976_/CLK _6976_/D VGND VGND VPWR VPWR _6976_/Q sky130_fd_sc_hd__dfxtp_2
XFILLER_110_24 VGND VGND VPWR VPWR sky130_fd_sc_hd__decap_3
XFILLER_110_35 VGND VGND VPWR VPWR sky130_fd_sc_hd__decap_3
XFILLER_13_208 VGND VGND VPWR VPWR sky130_fd_sc_hd__decap_3
XFILLER_34_580 VGND VGND VPWR VPWR sky130_fd_sc_hd__decap_3
XFILLER_53_399 VGND VGND VPWR VPWR sky130_fd_sc_hd__decap_3
XFILLER_80_163 VGND VGND VPWR VPWR sky130_fd_sc_hd__decap_3
XFILLER_110_68 VGND VGND VPWR VPWR sky130_fd_sc_hd__decap_3
XFILLER_21_252 VGND VGND VPWR VPWR sky130_fd_sc_hd__decap_3
XFILLER_21_263 VGND VGND VPWR VPWR sky130_fd_sc_hd__decap_3
XFILLER_21_296 VGND VGND VPWR VPWR sky130_fd_sc_hd__decap_3
X_4809_ _7002_/Q _4826_/A VGND VGND VPWR VPWR _7002_/D sky130_fd_sc_hd__xor2_2
XPHY_EDGE_ROW_17_Right_17 VGND VGND VPWR VPWR sky130_fd_sc_hd__decap_3
XFILLER_5_429 VGND VGND VPWR VPWR sky130_fd_sc_hd__decap_3
XFILLER_79_26 VGND VGND VPWR VPWR sky130_fd_sc_hd__decap_3
XFILLER_107_357 VGND VGND VPWR VPWR sky130_fd_sc_hd__decap_3
XTAP_TAPCELL_ROW_112_1600 VGND VPWR sky130_fd_sc_hd__tapvpwrvgnd_1
XFILLER_0_101 VGND VGND VPWR VPWR sky130_fd_sc_hd__decap_3
Xhold982 _7401_/Q VGND VGND VPWR VPWR hold982/X sky130_fd_sc_hd__dlygate4sd3_1
Xhold971 _7387_/Q VGND VGND VPWR VPWR hold971/X sky130_fd_sc_hd__dlygate4sd3_1
Xhold960 _7018_/Q VGND VGND VPWR VPWR _5619_/A sky130_fd_sc_hd__dlygate4sd3_1
XFILLER_103_552 VGND VGND VPWR VPWR sky130_fd_sc_hd__decap_3
XFILLER_1_646 VGND VGND VPWR VPWR sky130_fd_sc_hd__decap_3
XFILLER_49_606 VGND VGND VPWR VPWR sky130_fd_sc_hd__decap_3
Xhold993 _7399_/Q VGND VGND VPWR VPWR hold993/X sky130_fd_sc_hd__dlygate4sd3_1
XFILLER_0_167 VGND VGND VPWR VPWR sky130_fd_sc_hd__fill_1
XFILLER_1_679 VGND VGND VPWR VPWR sky130_fd_sc_hd__decap_3
XFILLER_48_105 VGND VGND VPWR VPWR sky130_fd_sc_hd__fill_1
XFILLER_49_617 VGND VGND VPWR VPWR sky130_fd_sc_hd__decap_3
XFILLER_76_414 VGND VGND VPWR VPWR sky130_fd_sc_hd__decap_3
XFILLER_88_263 VGND VGND VPWR VPWR sky130_fd_sc_hd__fill_1
XPHY_EDGE_ROW_26_Right_26 VGND VGND VPWR VPWR sky130_fd_sc_hd__decap_3
XFILLER_76_436 VGND VGND VPWR VPWR sky130_fd_sc_hd__decap_3
XFILLER_88_296 VGND VGND VPWR VPWR sky130_fd_sc_hd__fill_1
XFILLER_95_69 VGND VGND VPWR VPWR sky130_fd_sc_hd__decap_3
XFILLER_57_650 VGND VGND VPWR VPWR sky130_fd_sc_hd__decap_3
XFILLER_63_108 VGND VGND VPWR VPWR sky130_fd_sc_hd__decap_3
XFILLER_76_469 VGND VGND VPWR VPWR sky130_fd_sc_hd__decap_3
XFILLER_91_406 VGND VGND VPWR VPWR sky130_fd_sc_hd__decap_3
XTAP_TAPCELL_ROW_47_818 VGND VPWR sky130_fd_sc_hd__tapvpwrvgnd_1
XFILLER_29_396 VGND VGND VPWR VPWR sky130_fd_sc_hd__fill_1
XFILLER_56_171 VGND VGND VPWR VPWR sky130_fd_sc_hd__decap_3
XFILLER_84_480 VGND VGND VPWR VPWR sky130_fd_sc_hd__decap_3
XFILLER_71_141 VGND VGND VPWR VPWR sky130_fd_sc_hd__decap_3
XFILLER_72_642 VGND VGND VPWR VPWR sky130_fd_sc_hd__fill_2
XFILLER_72_675 VGND VGND VPWR VPWR sky130_fd_sc_hd__decap_3
XFILLER_44_377 VGND VGND VPWR VPWR sky130_fd_sc_hd__fill_1
XFILLER_44_399 VGND VGND VPWR VPWR sky130_fd_sc_hd__decap_3
XFILLER_44_40 VGND VGND VPWR VPWR sky130_fd_sc_hd__decap_3
XTAP_TAPCELL_ROW_63_1009 VGND VPWR sky130_fd_sc_hd__tapvpwrvgnd_1
XTAP_TAPCELL_ROW_27_575 VGND VPWR sky130_fd_sc_hd__tapvpwrvgnd_1
XFILLER_12_230 VGND VGND VPWR VPWR sky130_fd_sc_hd__decap_3
XFILLER_44_73 VGND VGND VPWR VPWR sky130_fd_sc_hd__decap_3
XFILLER_71_196 VGND VGND VPWR VPWR sky130_fd_sc_hd__decap_3
XPHY_EDGE_ROW_35_Right_35 VGND VGND VPWR VPWR sky130_fd_sc_hd__decap_3
XFILLER_12_274 VGND VGND VPWR VPWR sky130_fd_sc_hd__decap_3
XFILLER_8_256 VGND VGND VPWR VPWR sky130_fd_sc_hd__decap_3
XFILLER_8_267 VGND VGND VPWR VPWR sky130_fd_sc_hd__decap_3
XFILLER_5_12 VGND VGND VPWR VPWR sky130_fd_sc_hd__decap_3
XFILLER_8_289 VGND VGND VPWR VPWR sky130_fd_sc_hd__fill_1
Xoutput509 _3562_/B VGND VGND VPWR VPWR instruction_out[25] sky130_fd_sc_hd__clkdlybuf4s25_1
XFILLER_4_451 VGND VGND VPWR VPWR sky130_fd_sc_hd__decap_3
XFILLER_5_45 VGND VGND VPWR VPWR sky130_fd_sc_hd__decap_3
XFILLER_5_78 VGND VGND VPWR VPWR sky130_fd_sc_hd__decap_3
XTAP_TAPCELL_ROW_74_1138 VGND VPWR sky130_fd_sc_hd__tapvpwrvgnd_1
XFILLER_99_539 VGND VGND VPWR VPWR sky130_fd_sc_hd__decap_3
XFILLER_113_349 VGND VGND VPWR VPWR sky130_fd_sc_hd__fill_2
XFILLER_69_81 VGND VGND VPWR VPWR sky130_fd_sc_hd__decap_3
XPHY_EDGE_ROW_44_Right_44 VGND VGND VPWR VPWR sky130_fd_sc_hd__decap_3
XFILLER_79_252 VGND VGND VPWR VPWR sky130_fd_sc_hd__decap_3
XFILLER_94_200 VGND VGND VPWR VPWR sky130_fd_sc_hd__decap_3
XFILLER_39_127 VGND VGND VPWR VPWR sky130_fd_sc_hd__decap_3
XFILLER_67_447 VGND VGND VPWR VPWR sky130_fd_sc_hd__fill_1
XFILLER_48_672 VGND VGND VPWR VPWR sky130_fd_sc_hd__decap_3
XFILLER_55_609 VGND VGND VPWR VPWR sky130_fd_sc_hd__decap_3
XFILLER_67_469 VGND VGND VPWR VPWR sky130_fd_sc_hd__decap_3
XFILLER_94_277 VGND VGND VPWR VPWR sky130_fd_sc_hd__decap_3
XFILLER_63_620 VGND VGND VPWR VPWR sky130_fd_sc_hd__decap_3
XFILLER_35_333 VGND VGND VPWR VPWR sky130_fd_sc_hd__decap_3
XFILLER_35_355 VGND VGND VPWR VPWR sky130_fd_sc_hd__decap_3
XFILLER_47_193 VGND VGND VPWR VPWR sky130_fd_sc_hd__decap_3
XFILLER_62_141 VGND VGND VPWR VPWR sky130_fd_sc_hd__decap_3
XFILLER_63_653 VGND VGND VPWR VPWR sky130_fd_sc_hd__decap_3
X_6830_ _6975_/CLK _6830_/D VGND VGND VPWR VPWR _6830_/Q sky130_fd_sc_hd__dfxtp_2
XFILLER_23_528 VGND VGND VPWR VPWR sky130_fd_sc_hd__decap_3
XFILLER_35_399 VGND VGND VPWR VPWR sky130_fd_sc_hd__decap_3
X_6761_ _6975_/CLK _6761_/D VGND VGND VPWR VPWR _6761_/Q sky130_fd_sc_hd__dfxtp_2
XTAP_TAPCELL_ROW_85_1267 VGND VPWR sky130_fd_sc_hd__tapvpwrvgnd_1
X_5712_ _7362_/Q hold912/X _5721_/S VGND VGND VPWR VPWR _6706_/D sky130_fd_sc_hd__mux2_2
X_3973_ _7354_/Q _4515_/A0 _3989_/S VGND VGND VPWR VPWR _7354_/D sky130_fd_sc_hd__mux2_2
XPHY_EDGE_ROW_53_Right_53 VGND VGND VPWR VPWR sky130_fd_sc_hd__decap_3
XFILLER_31_561 VGND VGND VPWR VPWR sky130_fd_sc_hd__decap_3
X_6692_ _7384_/CLK _6692_/D VGND VGND VPWR VPWR _6692_/Q sky130_fd_sc_hd__dfxtp_2
X_5643_ _5643_/A VGND VGND VPWR VPWR _5643_/X sky130_fd_sc_hd__buf_1
X_5574_ hold949/X _5598_/A2 _4983_/X VGND VGND VPWR VPWR _7043_/D sky130_fd_sc_hd__a21o_2
X_7313_ clkload9/A _7313_/D _6593_/Y VGND VGND VPWR VPWR _7313_/Q sky130_fd_sc_hd__dfrtp_2
XFILLER_116_132 VGND VGND VPWR VPWR sky130_fd_sc_hd__decap_3
XFILLER_104_327 VGND VGND VPWR VPWR sky130_fd_sc_hd__decap_3
XFILLER_49_18 VGND VGND VPWR VPWR sky130_fd_sc_hd__decap_3
X_7244_ _7310_/CLK _7244_/D _6524_/Y VGND VGND VPWR VPWR _7244_/Q sky130_fd_sc_hd__dfrtp_2
X_4456_ _4456_/A _4054_/A VGND VGND VPWR VPWR _4456_/X sky130_fd_sc_hd__or2b_2
XPHY_EDGE_ROW_62_Right_62 VGND VGND VPWR VPWR sky130_fd_sc_hd__decap_3
X_7175_ _7337_/CLK _7175_/D _6455_/Y VGND VGND VPWR VPWR _7175_/Q sky130_fd_sc_hd__dfrtp_2
X_4387_ _7241_/Q _4430_/A2 _4430_/B1 _7177_/Q _4386_/X VGND VGND VPWR VPWR _4387_/X
+ sky130_fd_sc_hd__a221o_2
X_3407_ _3421_/B _3421_/C _3417_/C VGND VGND VPWR VPWR _3407_/X sky130_fd_sc_hd__and3_2
XFILLER_100_511 VGND VGND VPWR VPWR sky130_fd_sc_hd__fill_1
XFILLER_105_24 VGND VGND VPWR VPWR sky130_fd_sc_hd__decap_3
XFILLER_112_360 VGND VGND VPWR VPWR sky130_fd_sc_hd__decap_3
XFILLER_105_57 VGND VGND VPWR VPWR sky130_fd_sc_hd__decap_3
XFILLER_85_222 VGND VGND VPWR VPWR sky130_fd_sc_hd__fill_2
XFILLER_38_182 VGND VGND VPWR VPWR sky130_fd_sc_hd__decap_3
XFILLER_45_119 VGND VGND VPWR VPWR sky130_fd_sc_hd__decap_3
XFILLER_54_631 VGND VGND VPWR VPWR sky130_fd_sc_hd__decap_3
X_5008_ _4680_/A _5015_/B _5587_/B VGND VGND VPWR VPWR _5009_/B sky130_fd_sc_hd__a21o_2
XFILLER_26_355 VGND VGND VPWR VPWR sky130_fd_sc_hd__fill_2
XFILLER_26_388 VGND VGND VPWR VPWR sky130_fd_sc_hd__decap_3
XFILLER_53_152 VGND VGND VPWR VPWR sky130_fd_sc_hd__decap_3
XFILLER_54_675 VGND VGND VPWR VPWR sky130_fd_sc_hd__decap_3
XFILLER_81_27 VGND VGND VPWR VPWR sky130_fd_sc_hd__fill_2
XPHY_EDGE_ROW_71_Right_71 VGND VGND VPWR VPWR sky130_fd_sc_hd__decap_3
XFILLER_41_347 VGND VGND VPWR VPWR sky130_fd_sc_hd__fill_2
X_6959_ _6965_/CLK _6959_/D VGND VGND VPWR VPWR _6959_/Q sky130_fd_sc_hd__dfxtp_2
XTAP_TAPCELL_ROW_24_545 VGND VPWR sky130_fd_sc_hd__tapvpwrvgnd_1
XTAP_TAPCELL_ROW_24_534 VGND VPWR sky130_fd_sc_hd__tapvpwrvgnd_1
XFILLER_14_21 VGND VGND VPWR VPWR sky130_fd_sc_hd__decap_3
XFILLER_14_32 VGND VGND VPWR VPWR sky130_fd_sc_hd__decap_3
XTAP_TAPCELL_ROW_52_876 VGND VPWR sky130_fd_sc_hd__tapvpwrvgnd_1
XFILLER_14_65 VGND VGND VPWR VPWR sky130_fd_sc_hd__decap_3
XFILLER_108_622 VGND VGND VPWR VPWR sky130_fd_sc_hd__decap_3
XFILLER_30_20 VGND VGND VPWR VPWR sky130_fd_sc_hd__fill_1
XPHY_EDGE_ROW_15_Left_132 VGND VGND VPWR VPWR sky130_fd_sc_hd__decap_3
XFILLER_108_666 VGND VGND VPWR VPWR sky130_fd_sc_hd__decap_3
XFILLER_30_53 VGND VGND VPWR VPWR sky130_fd_sc_hd__decap_3
XPHY_EDGE_ROW_80_Right_80 VGND VGND VPWR VPWR sky130_fd_sc_hd__decap_3
XFILLER_30_97 VGND VGND VPWR VPWR sky130_fd_sc_hd__decap_3
XFILLER_1_432 VGND VGND VPWR VPWR sky130_fd_sc_hd__fill_2
XFILLER_96_509 VGND VGND VPWR VPWR sky130_fd_sc_hd__decap_3
Xhold790 _6818_/Q VGND VGND VPWR VPWR _6818_/D sky130_fd_sc_hd__dlygate4sd3_1
XFILLER_76_200 VGND VGND VPWR VPWR sky130_fd_sc_hd__decap_3
XFILLER_103_382 VGND VGND VPWR VPWR sky130_fd_sc_hd__decap_3
XFILLER_49_425 VGND VGND VPWR VPWR sky130_fd_sc_hd__decap_3
XFILLER_49_447 VGND VGND VPWR VPWR sky130_fd_sc_hd__fill_1
XFILLER_49_458 VGND VGND VPWR VPWR sky130_fd_sc_hd__decap_3
XFILLER_37_609 VGND VGND VPWR VPWR sky130_fd_sc_hd__decap_3
XFILLER_36_119 VGND VGND VPWR VPWR sky130_fd_sc_hd__decap_3
XFILLER_45_620 VGND VGND VPWR VPWR sky130_fd_sc_hd__decap_3
XFILLER_76_288 VGND VGND VPWR VPWR sky130_fd_sc_hd__decap_3
XFILLER_91_225 VGND VGND VPWR VPWR sky130_fd_sc_hd__decap_3
XFILLER_91_236 VGND VGND VPWR VPWR sky130_fd_sc_hd__decap_3
XPHY_EDGE_ROW_24_Left_141 VGND VGND VPWR VPWR sky130_fd_sc_hd__decap_3
XFILLER_29_193 VGND VGND VPWR VPWR sky130_fd_sc_hd__decap_3
XFILLER_45_664 VGND VGND VPWR VPWR sky130_fd_sc_hd__decap_3
XFILLER_55_72 VGND VGND VPWR VPWR sky130_fd_sc_hd__decap_3
XFILLER_72_450 VGND VGND VPWR VPWR sky130_fd_sc_hd__fill_1
XFILLER_17_366 VGND VGND VPWR VPWR sky130_fd_sc_hd__decap_3
XFILLER_17_388 VGND VGND VPWR VPWR sky130_fd_sc_hd__decap_3
XFILLER_32_303 VGND VGND VPWR VPWR sky130_fd_sc_hd__fill_1
XFILLER_60_601 VGND VGND VPWR VPWR sky130_fd_sc_hd__decap_3
XFILLER_60_634 VGND VGND VPWR VPWR sky130_fd_sc_hd__decap_3
XFILLER_60_645 VGND VGND VPWR VPWR sky130_fd_sc_hd__decap_3
XFILLER_13_561 VGND VGND VPWR VPWR sky130_fd_sc_hd__decap_3
XFILLER_60_678 VGND VGND VPWR VPWR sky130_fd_sc_hd__decap_3
XFILLER_72_6 VGND VGND VPWR VPWR sky130_fd_sc_hd__decap_3
XPHY_EDGE_ROW_33_Left_150 VGND VGND VPWR VPWR sky130_fd_sc_hd__decap_3
XFILLER_113_102 VGND VGND VPWR VPWR sky130_fd_sc_hd__decap_3
XFILLER_113_113 VGND VGND VPWR VPWR sky130_fd_sc_hd__decap_3
XFILLER_114_625 VGND VGND VPWR VPWR sky130_fd_sc_hd__decap_3
X_5290_ _5290_/A0 _5156_/X _5292_/S VGND VGND VPWR VPWR _7184_/D sky130_fd_sc_hd__mux2_2
X_4310_ _7352_/Q _3449_/X _4334_/B1 _7160_/Q VGND VGND VPWR VPWR _4311_/C sky130_fd_sc_hd__a22o_2
XFILLER_99_325 VGND VGND VPWR VPWR sky130_fd_sc_hd__decap_3
XFILLER_113_146 VGND VGND VPWR VPWR sky130_fd_sc_hd__decap_3
XFILLER_114_669 VGND VGND VPWR VPWR sky130_fd_sc_hd__decap_3
XFILLER_4_292 VGND VGND VPWR VPWR sky130_fd_sc_hd__decap_3
X_4241_ _5018_/B _4241_/B VGND VGND VPWR VPWR _5032_/A sky130_fd_sc_hd__or2_2
XFILLER_99_369 VGND VGND VPWR VPWR sky130_fd_sc_hd__decap_3
XFILLER_101_319 VGND VGND VPWR VPWR sky130_fd_sc_hd__decap_3
X_4172_ _4938_/B _4379_/B VGND VGND VPWR VPWR _4936_/A sky130_fd_sc_hd__nor2_2
XFILLER_95_564 VGND VGND VPWR VPWR sky130_fd_sc_hd__fill_2
XFILLER_27_119 VGND VGND VPWR VPWR sky130_fd_sc_hd__decap_3
XFILLER_82_203 VGND VGND VPWR VPWR sky130_fd_sc_hd__decap_3
XFILLER_36_642 VGND VGND VPWR VPWR sky130_fd_sc_hd__fill_2
XFILLER_36_686 VGND VGND VPWR VPWR sky130_fd_sc_hd__decap_3
XFILLER_51_623 VGND VGND VPWR VPWR sky130_fd_sc_hd__decap_3
XFILLER_23_347 VGND VGND VPWR VPWR sky130_fd_sc_hd__decap_3
XFILLER_35_196 VGND VGND VPWR VPWR sky130_fd_sc_hd__decap_3
XFILLER_51_656 VGND VGND VPWR VPWR sky130_fd_sc_hd__decap_3
XFILLER_90_280 VGND VGND VPWR VPWR sky130_fd_sc_hd__decap_3
Xplace450 _7010_/Q VGND VGND VPWR VPWR _7010_/D sky130_fd_sc_hd__buf_2
Xplace461 _3362_/A VGND VGND VPWR VPWR _3403_/A sky130_fd_sc_hd__buf_2
X_6813_ _6909_/CLK _6813_/D VGND VGND VPWR VPWR _6813_/Q sky130_fd_sc_hd__dfxtp_2
XFILLER_50_155 VGND VGND VPWR VPWR sky130_fd_sc_hd__decap_3
X_6744_ _6978_/CLK _6744_/D VGND VGND VPWR VPWR _6744_/Q sky130_fd_sc_hd__dfxtp_2
X_3956_ _7362_/Q _4499_/A0 _3962_/S VGND VGND VPWR VPWR _7362_/D sky130_fd_sc_hd__mux2_2
XFILLER_31_380 VGND VGND VPWR VPWR sky130_fd_sc_hd__decap_3
XFILLER_50_188 VGND VGND VPWR VPWR sky130_fd_sc_hd__decap_3
X_6675_ _6675_/A VGND VGND VPWR VPWR _6675_/Y sky130_fd_sc_hd__inv_2
XTAP_TAPCELL_ROW_21_504 VGND VPWR sky130_fd_sc_hd__tapvpwrvgnd_1
XFILLER_109_408 VGND VGND VPWR VPWR sky130_fd_sc_hd__decap_3
X_5626_ _5626_/A _5634_/B VGND VGND VPWR VPWR _7015_/D sky130_fd_sc_hd__and2_2
X_3887_ _6694_/Q _3887_/A2 _3917_/B1 _6872_/Q _3886_/X VGND VGND VPWR VPWR _3887_/X
+ sky130_fd_sc_hd__a221o_2
XTAP_TAPCELL_ROW_98_1425 VGND VPWR sky130_fd_sc_hd__tapvpwrvgnd_1
XFILLER_105_647 VGND VGND VPWR VPWR sky130_fd_sc_hd__decap_3
XFILLER_4_9 VGND VGND VPWR VPWR sky130_fd_sc_hd__decap_3
X_7227_ clkload4/A _7227_/D _6507_/Y VGND VGND VPWR VPWR _7227_/Q sky130_fd_sc_hd__dfrtp_2
X_4439_ _4440_/A _4650_/B VGND VGND VPWR VPWR _4813_/B sky130_fd_sc_hd__or2_2
XFILLER_58_200 VGND VGND VPWR VPWR sky130_fd_sc_hd__decap_3
XFILLER_76_38 VGND VGND VPWR VPWR sky130_fd_sc_hd__decap_3
XFILLER_86_542 VGND VGND VPWR VPWR sky130_fd_sc_hd__decap_3
X_7158_ clkload3/A _7158_/D _6438_/Y VGND VGND VPWR VPWR _7158_/Q sky130_fd_sc_hd__dfrtp_2
XFILLER_98_391 VGND VGND VPWR VPWR sky130_fd_sc_hd__decap_3
X_7089_ _7312_/CLK _7089_/D _6369_/Y VGND VGND VPWR VPWR _7089_/Q sky130_fd_sc_hd__dfstp_2
XFILLER_100_374 VGND VGND VPWR VPWR sky130_fd_sc_hd__decap_3
XFILLER_46_439 VGND VGND VPWR VPWR sky130_fd_sc_hd__fill_1
XFILLER_58_277 VGND VGND VPWR VPWR sky130_fd_sc_hd__decap_3
XFILLER_58_299 VGND VGND VPWR VPWR sky130_fd_sc_hd__decap_3
XFILLER_73_225 VGND VGND VPWR VPWR sky130_fd_sc_hd__fill_2
XFILLER_86_597 VGND VGND VPWR VPWR sky130_fd_sc_hd__decap_3
XTAP_TAPCELL_ROW_57_935 VGND VPWR sky130_fd_sc_hd__tapvpwrvgnd_1
XTAP_TAPCELL_ROW_29_604 VGND VPWR sky130_fd_sc_hd__tapvpwrvgnd_1
XFILLER_61_409 VGND VGND VPWR VPWR sky130_fd_sc_hd__fill_2
XFILLER_73_269 VGND VGND VPWR VPWR sky130_fd_sc_hd__decap_3
XFILLER_92_15 VGND VGND VPWR VPWR sky130_fd_sc_hd__fill_2
XTAP_TAPCELL_ROW_107_1532 VGND VPWR sky130_fd_sc_hd__tapvpwrvgnd_1
XFILLER_26_163 VGND VGND VPWR VPWR sky130_fd_sc_hd__decap_3
XTAP_TAPCELL_ROW_1_262 VGND VPWR sky130_fd_sc_hd__tapvpwrvgnd_1
XFILLER_25_42 VGND VGND VPWR VPWR sky130_fd_sc_hd__fill_1
XFILLER_41_122 VGND VGND VPWR VPWR sky130_fd_sc_hd__decap_3
XFILLER_42_656 VGND VGND VPWR VPWR sky130_fd_sc_hd__decap_3
XFILLER_54_494 VGND VGND VPWR VPWR sky130_fd_sc_hd__decap_3
XTAP_TAPCELL_ROW_37_692 VGND VPWR sky130_fd_sc_hd__tapvpwrvgnd_1
XFILLER_25_75 VGND VGND VPWR VPWR sky130_fd_sc_hd__decap_3
XFILLER_42_689 VGND VGND VPWR VPWR sky130_fd_sc_hd__decap_3
XFILLER_41_199 VGND VGND VPWR VPWR sky130_fd_sc_hd__decap_3
XFILLER_41_63 VGND VGND VPWR VPWR sky130_fd_sc_hd__decap_3
XFILLER_6_524 VGND VGND VPWR VPWR sky130_fd_sc_hd__decap_3
XFILLER_41_96 VGND VGND VPWR VPWR sky130_fd_sc_hd__decap_3
XTAP_TAPCELL_ROW_71_1108 VGND VPWR sky130_fd_sc_hd__tapvpwrvgnd_1
XFILLER_111_606 VGND VGND VPWR VPWR sky130_fd_sc_hd__decap_3
XFILLER_111_617 VGND VGND VPWR VPWR sky130_fd_sc_hd__decap_3
XFILLER_37_9 VGND VGND VPWR VPWR sky130_fd_sc_hd__decap_3
XFILLER_96_306 VGND VGND VPWR VPWR sky130_fd_sc_hd__fill_2
XTAP_TAPCELL_ROW_9_362 VGND VPWR sky130_fd_sc_hd__tapvpwrvgnd_1
XFILLER_110_127 VGND VGND VPWR VPWR sky130_fd_sc_hd__decap_3
XFILLER_2_35 VGND VGND VPWR VPWR sky130_fd_sc_hd__decap_3
XFILLER_49_233 VGND VGND VPWR VPWR sky130_fd_sc_hd__decap_3
XFILLER_77_520 VGND VGND VPWR VPWR sky130_fd_sc_hd__fill_1
XFILLER_2_68 VGND VGND VPWR VPWR sky130_fd_sc_hd__decap_3
XFILLER_37_428 VGND VGND VPWR VPWR sky130_fd_sc_hd__decap_3
XFILLER_64_203 VGND VGND VPWR VPWR sky130_fd_sc_hd__decap_3
XFILLER_64_214 VGND VGND VPWR VPWR sky130_fd_sc_hd__decap_3
XFILLER_66_60 VGND VGND VPWR VPWR sky130_fd_sc_hd__decap_3
XFILLER_77_597 VGND VGND VPWR VPWR sky130_fd_sc_hd__decap_3
XFILLER_17_163 VGND VGND VPWR VPWR sky130_fd_sc_hd__decap_3
XFILLER_18_675 VGND VGND VPWR VPWR sky130_fd_sc_hd__fill_1
XFILLER_45_472 VGND VGND VPWR VPWR sky130_fd_sc_hd__decap_3
XFILLER_32_100 VGND VGND VPWR VPWR sky130_fd_sc_hd__decap_3
XFILLER_32_122 VGND VGND VPWR VPWR sky130_fd_sc_hd__decap_3
XFILLER_33_656 VGND VGND VPWR VPWR sky130_fd_sc_hd__decap_3
XFILLER_72_291 VGND VGND VPWR VPWR sky130_fd_sc_hd__decap_3
XTAP_TAPCELL_ROW_82_1237 VGND VPWR sky130_fd_sc_hd__tapvpwrvgnd_1
XFILLER_20_306 VGND VGND VPWR VPWR sky130_fd_sc_hd__fill_2
XFILLER_32_144 VGND VGND VPWR VPWR sky130_fd_sc_hd__decap_3
X_4790_ _4781_/X _4782_/Y _4787_/Y _4948_/A _4789_/X VGND VGND VPWR VPWR _5664_/A
+ sky130_fd_sc_hd__o221a_2
X_3810_ _6846_/Q _3892_/A2 _3889_/B1 _6831_/Q _3809_/X VGND VGND VPWR VPWR _3810_/X
+ sky130_fd_sc_hd__a221o_2
XFILLER_60_486 VGND VGND VPWR VPWR sky130_fd_sc_hd__decap_3
X_3741_ _3746_/A _3741_/B _3746_/C VGND VGND VPWR VPWR _3741_/X sky130_fd_sc_hd__and3_4
XFILLER_9_340 VGND VGND VPWR VPWR sky130_fd_sc_hd__decap_3
XFILLER_70_3 VGND VGND VPWR VPWR sky130_fd_sc_hd__decap_3
X_6460_ _6558_/A VGND VGND VPWR VPWR _6460_/Y sky130_fd_sc_hd__inv_2
X_3672_ _3746_/A _3746_/B _3733_/C VGND VGND VPWR VPWR _3672_/X sky130_fd_sc_hd__or3_2
X_6391_ _6553_/A VGND VGND VPWR VPWR _6391_/Y sky130_fd_sc_hd__inv_2
X_5411_ _5411_/A0 _5094_/X _5423_/S VGND VGND VPWR VPWR _7128_/D sky130_fd_sc_hd__mux2_2
X_5342_ _5342_/A0 _5094_/X _5358_/S VGND VGND VPWR VPWR _7160_/D sky130_fd_sc_hd__mux2_2
XFILLER_99_111 VGND VGND VPWR VPWR sky130_fd_sc_hd__fill_1
XTAP_TAPCELL_ROW_93_1366 VGND VPWR sky130_fd_sc_hd__tapvpwrvgnd_1
XFILLER_99_122 VGND VGND VPWR VPWR sky130_fd_sc_hd__decap_3
XFILLER_114_477 VGND VGND VPWR VPWR sky130_fd_sc_hd__fill_2
X_7012_ _7387_/CLK _7012_/D _6292_/Y VGND VGND VPWR VPWR _7012_/Q sky130_fd_sc_hd__dfrtp_2
XFILLER_101_116 VGND VGND VPWR VPWR sky130_fd_sc_hd__fill_2
XFILLER_102_639 VGND VGND VPWR VPWR sky130_fd_sc_hd__decap_3
XFILLER_68_531 VGND VGND VPWR VPWR sky130_fd_sc_hd__fill_1
X_4224_ _4371_/A _4371_/B _4224_/C VGND VGND VPWR VPWR _4372_/A sky130_fd_sc_hd__and3_2
X_4155_ _4151_/X _4154_/X _4425_/A VGND VGND VPWR VPWR _4205_/C sky130_fd_sc_hd__o21ai_2
XFILLER_110_672 VGND VGND VPWR VPWR sky130_fd_sc_hd__decap_3
XFILLER_55_225 VGND VGND VPWR VPWR sky130_fd_sc_hd__fill_2
XFILLER_55_236 VGND VGND VPWR VPWR sky130_fd_sc_hd__decap_3
X_4086_ _7270_/Q _4422_/A2 _3958_/S _7334_/Q _4085_/X VGND VGND VPWR VPWR _4086_/X
+ sky130_fd_sc_hd__a221o_2
XFILLER_55_269 VGND VGND VPWR VPWR sky130_fd_sc_hd__fill_2
XTAP_TAPCELL_ROW_54_905 VGND VPWR sky130_fd_sc_hd__tapvpwrvgnd_1
XFILLER_102_58 VGND VGND VPWR VPWR sky130_fd_sc_hd__decap_3
XFILLER_23_111 VGND VGND VPWR VPWR sky130_fd_sc_hd__fill_1
XFILLER_23_122 VGND VGND VPWR VPWR sky130_fd_sc_hd__decap_3
XFILLER_24_623 VGND VGND VPWR VPWR sky130_fd_sc_hd__decap_3
XFILLER_36_494 VGND VGND VPWR VPWR sky130_fd_sc_hd__fill_2
XFILLER_62_18 VGND VGND VPWR VPWR sky130_fd_sc_hd__decap_3
Xplace291 _3862_/B1 VGND VGND VPWR VPWR _3926_/B1 sky130_fd_sc_hd__buf_2
Xplace280 _3661_/X VGND VGND VPWR VPWR _3886_/A2 sky130_fd_sc_hd__buf_2
XFILLER_11_328 VGND VGND VPWR VPWR sky130_fd_sc_hd__decap_3
XFILLER_23_199 VGND VGND VPWR VPWR sky130_fd_sc_hd__decap_3
X_4988_ _4988_/A _4988_/B VGND VGND VPWR VPWR _5004_/A sky130_fd_sc_hd__nor2_2
XTAP_TAPCELL_ROW_62_993 VGND VPWR sky130_fd_sc_hd__tapvpwrvgnd_1
XTAP_TAPCELL_ROW_34_662 VGND VPWR sky130_fd_sc_hd__tapvpwrvgnd_1
XTAP_TAPCELL_ROW_102_1473 VGND VPWR sky130_fd_sc_hd__tapvpwrvgnd_1
XFILLER_109_205 VGND VGND VPWR VPWR sky130_fd_sc_hd__decap_3
X_6727_ clkload2/A _6727_/D VGND VGND VPWR VPWR _6727_/Q sky130_fd_sc_hd__dfxtp_2
X_3939_ _7370_/Q _4482_/A0 _3945_/S VGND VGND VPWR VPWR _7370_/D sky130_fd_sc_hd__mux2_2
X_6658_ _6660_/A VGND VGND VPWR VPWR _6658_/Y sky130_fd_sc_hd__inv_2
XFILLER_109_249 VGND VGND VPWR VPWR sky130_fd_sc_hd__decap_3
XFILLER_11_33 VGND VGND VPWR VPWR sky130_fd_sc_hd__decap_3
X_5609_ _5609_/A _5622_/B VGND VGND VPWR VPWR _7023_/D sky130_fd_sc_hd__or2_2
XFILLER_105_411 VGND VGND VPWR VPWR sky130_fd_sc_hd__decap_3
XFILLER_11_66 VGND VGND VPWR VPWR sky130_fd_sc_hd__decap_3
X_6589_ _6651_/A VGND VGND VPWR VPWR _6589_/Y sky130_fd_sc_hd__inv_2
XFILLER_11_99 VGND VGND VPWR VPWR sky130_fd_sc_hd__decap_3
XFILLER_3_538 VGND VGND VPWR VPWR sky130_fd_sc_hd__decap_3
XFILLER_87_15 VGND VGND VPWR VPWR sky130_fd_sc_hd__decap_3
XFILLER_105_455 VGND VGND VPWR VPWR sky130_fd_sc_hd__decap_3
XFILLER_105_477 VGND VGND VPWR VPWR sky130_fd_sc_hd__decap_3
XTAP_TAPCELL_ROW_6_321 VGND VPWR sky130_fd_sc_hd__tapvpwrvgnd_1
XFILLER_101_650 VGND VGND VPWR VPWR sky130_fd_sc_hd__decap_3
XFILLER_19_439 VGND VGND VPWR VPWR sky130_fd_sc_hd__decap_3
XFILLER_46_203 VGND VGND VPWR VPWR sky130_fd_sc_hd__decap_3
XFILLER_59_575 VGND VGND VPWR VPWR sky130_fd_sc_hd__decap_3
XFILLER_100_171 VGND VGND VPWR VPWR sky130_fd_sc_hd__decap_3
XFILLER_46_236 VGND VGND VPWR VPWR sky130_fd_sc_hd__decap_3
XFILLER_74_545 VGND VGND VPWR VPWR sky130_fd_sc_hd__fill_1
XFILLER_74_556 VGND VGND VPWR VPWR sky130_fd_sc_hd__decap_3
XFILLER_61_217 VGND VGND VPWR VPWR sky130_fd_sc_hd__decap_3
XFILLER_15_634 VGND VGND VPWR VPWR sky130_fd_sc_hd__decap_3
XFILLER_36_85 VGND VGND VPWR VPWR sky130_fd_sc_hd__fill_1
XFILLER_61_228 VGND VGND VPWR VPWR sky130_fd_sc_hd__fill_2
XFILLER_61_239 VGND VGND VPWR VPWR sky130_fd_sc_hd__fill_2
XTAP_TAPCELL_ROW_68_1070 VGND VPWR sky130_fd_sc_hd__tapvpwrvgnd_1
XFILLER_14_155 VGND VGND VPWR VPWR sky130_fd_sc_hd__decap_3
XFILLER_30_626 VGND VGND VPWR VPWR sky130_fd_sc_hd__decap_3
XFILLER_42_475 VGND VGND VPWR VPWR sky130_fd_sc_hd__fill_1
XFILLER_10_350 VGND VGND VPWR VPWR sky130_fd_sc_hd__fill_2
XFILLER_115_208 VGND VGND VPWR VPWR sky130_fd_sc_hd__decap_3
XFILLER_6_365 VGND VGND VPWR VPWR sky130_fd_sc_hd__decap_3
XFILLER_96_103 VGND VGND VPWR VPWR sky130_fd_sc_hd__decap_3
XFILLER_97_615 VGND VGND VPWR VPWR sky130_fd_sc_hd__fill_1
XFILLER_97_626 VGND VGND VPWR VPWR sky130_fd_sc_hd__decap_3
XFILLER_96_136 VGND VGND VPWR VPWR sky130_fd_sc_hd__decap_3
XFILLER_97_659 VGND VGND VPWR VPWR sky130_fd_sc_hd__decap_3
XFILLER_111_469 VGND VGND VPWR VPWR sky130_fd_sc_hd__fill_2
XFILLER_84_309 VGND VGND VPWR VPWR sky130_fd_sc_hd__decap_3
XFILLER_96_147 VGND VGND VPWR VPWR sky130_fd_sc_hd__decap_3
XFILLER_37_225 VGND VGND VPWR VPWR sky130_fd_sc_hd__decap_3
XFILLER_37_236 VGND VGND VPWR VPWR sky130_fd_sc_hd__decap_3
XFILLER_37_269 VGND VGND VPWR VPWR sky130_fd_sc_hd__decap_3
XFILLER_52_217 VGND VGND VPWR VPWR sky130_fd_sc_hd__decap_3
XFILLER_80_504 VGND VGND VPWR VPWR sky130_fd_sc_hd__decap_3
XFILLER_92_386 VGND VGND VPWR VPWR sky130_fd_sc_hd__decap_3
X_4911_ _6997_/Q _4931_/A VGND VGND VPWR VPWR _4912_/B sky130_fd_sc_hd__nor2_2
XFILLER_20_114 VGND VGND VPWR VPWR sky130_fd_sc_hd__decap_3
XFILLER_21_637 VGND VGND VPWR VPWR sky130_fd_sc_hd__decap_3
X_4842_ _4643_/Y _4841_/Y _4845_/A VGND VGND VPWR VPWR _4842_/X sky130_fd_sc_hd__a21o_2
XFILLER_20_147 VGND VGND VPWR VPWR sky130_fd_sc_hd__decap_3
XTAP_TAPCELL_ROW_31_621 VGND VPWR sky130_fd_sc_hd__tapvpwrvgnd_1
X_6512_ _6608_/A VGND VGND VPWR VPWR _6512_/Y sky130_fd_sc_hd__inv_2
X_3724_ _6828_/Q _3879_/A2 _3882_/A2 _6818_/Q _3723_/X VGND VGND VPWR VPWR _3724_/X
+ sky130_fd_sc_hd__a221o_2
X_6443_ _6570_/A VGND VGND VPWR VPWR _6443_/Y sky130_fd_sc_hd__inv_2
X_6374_ _6539_/A VGND VGND VPWR VPWR _6374_/Y sky130_fd_sc_hd__inv_2
X_3586_ _3591_/A _3591_/B _3591_/C _3586_/D VGND VGND VPWR VPWR _3586_/Y sky130_fd_sc_hd__nor4_2
XFILLER_114_230 VGND VGND VPWR VPWR sky130_fd_sc_hd__decap_3
XFILLER_88_626 VGND VGND VPWR VPWR sky130_fd_sc_hd__decap_3
X_5325_ _5325_/A0 _4964_/X _5360_/S VGND VGND VPWR VPWR _7168_/D sky130_fd_sc_hd__mux2_2
XFILLER_102_436 VGND VGND VPWR VPWR sky130_fd_sc_hd__decap_3
XFILLER_114_274 VGND VGND VPWR VPWR sky130_fd_sc_hd__decap_3
XFILLER_87_125 VGND VGND VPWR VPWR sky130_fd_sc_hd__decap_3
XFILLER_88_648 VGND VGND VPWR VPWR sky130_fd_sc_hd__decap_3
X_5256_ _5256_/A0 _4932_/X _5262_/S VGND VGND VPWR VPWR _7202_/D sky130_fd_sc_hd__mux2_2
XFILLER_102_469 VGND VGND VPWR VPWR sky130_fd_sc_hd__decap_3
XFILLER_87_158 VGND VGND VPWR VPWR sky130_fd_sc_hd__fill_2
XFILLER_87_169 VGND VGND VPWR VPWR sky130_fd_sc_hd__decap_3
X_4207_ _4207_/A _4642_/B VGND VGND VPWR VPWR _4208_/B sky130_fd_sc_hd__and2_2
XFILLER_28_203 VGND VGND VPWR VPWR sky130_fd_sc_hd__decap_3
XFILLER_68_361 VGND VGND VPWR VPWR sky130_fd_sc_hd__decap_3
XFILLER_96_681 VGND VGND VPWR VPWR sky130_fd_sc_hd__decap_3
XFILLER_113_24 VGND VGND VPWR VPWR sky130_fd_sc_hd__decap_3
XFILLER_28_225 VGND VGND VPWR VPWR sky130_fd_sc_hd__decap_3
XFILLER_83_320 VGND VGND VPWR VPWR sky130_fd_sc_hd__decap_3
X_4138_ _4134_/X _4137_/X _4425_/A VGND VGND VPWR VPWR _4642_/B sky130_fd_sc_hd__o21a_2
XTAP_TAPCELL_ROW_39_721 VGND VPWR sky130_fd_sc_hd__tapvpwrvgnd_1
XFILLER_113_57 VGND VGND VPWR VPWR sky130_fd_sc_hd__decap_3
XFILLER_56_578 VGND VGND VPWR VPWR sky130_fd_sc_hd__decap_3
XFILLER_56_589 VGND VGND VPWR VPWR sky130_fd_sc_hd__decap_3
X_4069_ _4744_/B _4069_/B VGND VGND VPWR VPWR _4069_/Y sky130_fd_sc_hd__nor2_2
XFILLER_83_386 VGND VGND VPWR VPWR sky130_fd_sc_hd__decap_3
XTAP_TAPCELL_ROW_104_1502 VGND VPWR sky130_fd_sc_hd__tapvpwrvgnd_1
XFILLER_24_431 VGND VGND VPWR VPWR sky130_fd_sc_hd__decap_3
XFILLER_24_475 VGND VGND VPWR VPWR sky130_fd_sc_hd__fill_1
XFILLER_11_125 VGND VGND VPWR VPWR sky130_fd_sc_hd__decap_3
XFILLER_51_294 VGND VGND VPWR VPWR sky130_fd_sc_hd__decap_3
XFILLER_11_158 VGND VGND VPWR VPWR sky130_fd_sc_hd__decap_3
XFILLER_11_169 VGND VGND VPWR VPWR sky130_fd_sc_hd__fill_2
XFILLER_22_21 VGND VGND VPWR VPWR sky130_fd_sc_hd__decap_3
XFILLER_3_313 VGND VGND VPWR VPWR sky130_fd_sc_hd__fill_1
XFILLER_3_335 VGND VGND VPWR VPWR sky130_fd_sc_hd__fill_1
XTAP_TAPCELL_ROW_115_1631 VGND VPWR sky130_fd_sc_hd__tapvpwrvgnd_1
XFILLER_98_47 VGND VGND VPWR VPWR sky130_fd_sc_hd__decap_3
XFILLER_105_252 VGND VGND VPWR VPWR sky130_fd_sc_hd__decap_3
XFILLER_79_626 VGND VGND VPWR VPWR sky130_fd_sc_hd__decap_3
XFILLER_79_659 VGND VGND VPWR VPWR sky130_fd_sc_hd__decap_3
XFILLER_78_136 VGND VGND VPWR VPWR sky130_fd_sc_hd__decap_3
XFILLER_94_618 VGND VGND VPWR VPWR sky130_fd_sc_hd__decap_3
XFILLER_19_203 VGND VGND VPWR VPWR sky130_fd_sc_hd__decap_3
XFILLER_47_501 VGND VGND VPWR VPWR sky130_fd_sc_hd__decap_3
XFILLER_101_491 VGND VGND VPWR VPWR sky130_fd_sc_hd__fill_2
XFILLER_74_342 VGND VGND VPWR VPWR sky130_fd_sc_hd__decap_3
XFILLER_86_191 VGND VGND VPWR VPWR sky130_fd_sc_hd__decap_3
XFILLER_34_206 VGND VGND VPWR VPWR sky130_fd_sc_hd__decap_3
XFILLER_47_95 VGND VGND VPWR VPWR sky130_fd_sc_hd__decap_3
XFILLER_74_397 VGND VGND VPWR VPWR sky130_fd_sc_hd__decap_3
XFILLER_63_50 VGND VGND VPWR VPWR sky130_fd_sc_hd__decap_3
XTAP_TAPCELL_ROW_17_459 VGND VPWR sky130_fd_sc_hd__tapvpwrvgnd_1
XFILLER_15_486 VGND VGND VPWR VPWR sky130_fd_sc_hd__decap_3
XFILLER_63_83 VGND VGND VPWR VPWR sky130_fd_sc_hd__decap_3
XFILLER_70_592 VGND VGND VPWR VPWR sky130_fd_sc_hd__decap_3
XFILLER_8_23 VGND VGND VPWR VPWR sky130_fd_sc_hd__fill_2
XFILLER_8_56 VGND VGND VPWR VPWR sky130_fd_sc_hd__decap_3
XPHY_EDGE_ROW_7_Left_124 VGND VGND VPWR VPWR sky130_fd_sc_hd__decap_3
XFILLER_11_670 VGND VGND VPWR VPWR sky130_fd_sc_hd__fill_2
XFILLER_7_630 VGND VGND VPWR VPWR sky130_fd_sc_hd__decap_3
XFILLER_116_528 VGND VGND VPWR VPWR sky130_fd_sc_hd__decap_3
XFILLER_7_663 VGND VGND VPWR VPWR sky130_fd_sc_hd__decap_3
XFILLER_7_685 VGND VGND VPWR VPWR sky130_fd_sc_hd__decap_3
Xhold608 _6873_/Q VGND VGND VPWR VPWR _6873_/D sky130_fd_sc_hd__dlygate4sd3_1
XFILLER_109_591 VGND VGND VPWR VPWR sky130_fd_sc_hd__decap_3
Xhold619 _6801_/Q VGND VGND VPWR VPWR _6801_/D sky130_fd_sc_hd__dlygate4sd3_1
X_3440_ _7250_/Q _4601_/S _3434_/X _3439_/X VGND VGND VPWR VPWR _3440_/X sky130_fd_sc_hd__a211o_2
XFILLER_97_401 VGND VGND VPWR VPWR sky130_fd_sc_hd__decap_3
X_3371_ _3371_/A _5118_/D _5118_/A _3362_/A VGND VGND VPWR VPWR _3371_/Y sky130_fd_sc_hd__nor4bb_2
XFILLER_111_211 VGND VGND VPWR VPWR sky130_fd_sc_hd__decap_3
XFILLER_33_3 VGND VGND VPWR VPWR sky130_fd_sc_hd__decap_3
XFILLER_97_412 VGND VGND VPWR VPWR sky130_fd_sc_hd__fill_1
XFILLER_97_434 VGND VGND VPWR VPWR sky130_fd_sc_hd__decap_3
X_5110_ _3610_/A _3603_/Y _4292_/C VGND VGND VPWR VPWR _5110_/Y sky130_fd_sc_hd__a21oi_2
XTAP_TAPCELL_ROW_90_1336 VGND VPWR sky130_fd_sc_hd__tapvpwrvgnd_1
XFILLER_69_147 VGND VGND VPWR VPWR sky130_fd_sc_hd__decap_3
XFILLER_97_467 VGND VGND VPWR VPWR sky130_fd_sc_hd__decap_3
X_5041_ _5041_/A0 _5040_/X _5136_/S VGND VGND VPWR VPWR _7259_/D sky130_fd_sc_hd__mux2_2
XFILLER_69_169 VGND VGND VPWR VPWR sky130_fd_sc_hd__decap_3
XFILLER_78_681 VGND VGND VPWR VPWR sky130_fd_sc_hd__decap_3
XFILLER_84_117 VGND VGND VPWR VPWR sky130_fd_sc_hd__decap_3
XFILLER_85_629 VGND VGND VPWR VPWR sky130_fd_sc_hd__decap_3
XFILLER_97_489 VGND VGND VPWR VPWR sky130_fd_sc_hd__fill_2
XFILLER_111_299 VGND VGND VPWR VPWR sky130_fd_sc_hd__decap_3
XFILLER_65_331 VGND VGND VPWR VPWR sky130_fd_sc_hd__decap_3
XFILLER_65_375 VGND VGND VPWR VPWR sky130_fd_sc_hd__decap_3
XFILLER_80_301 VGND VGND VPWR VPWR sky130_fd_sc_hd__decap_3
XFILLER_93_662 VGND VGND VPWR VPWR sky130_fd_sc_hd__decap_3
XFILLER_93_673 VGND VGND VPWR VPWR sky130_fd_sc_hd__decap_3
XFILLER_53_548 VGND VGND VPWR VPWR sky130_fd_sc_hd__fill_2
XFILLER_92_194 VGND VGND VPWR VPWR sky130_fd_sc_hd__fill_2
X_6992_ _7398_/CLK _6992_/D _6272_/Y VGND VGND VPWR VPWR _6992_/Q sky130_fd_sc_hd__dfrtp_2
XFILLER_61_581 VGND VGND VPWR VPWR sky130_fd_sc_hd__decap_3
XFILLER_80_389 VGND VGND VPWR VPWR sky130_fd_sc_hd__decap_3
XFILLER_33_294 VGND VGND VPWR VPWR sky130_fd_sc_hd__decap_3
X_4825_ _7001_/Q _4825_/B VGND VGND VPWR VPWR _4826_/B sky130_fd_sc_hd__nor2_2
XFILLER_107_517 VGND VGND VPWR VPWR sky130_fd_sc_hd__decap_3
X_4687_ _7001_/Q _4687_/B VGND VGND VPWR VPWR _4834_/A sky130_fd_sc_hd__and2_2
X_3707_ _6937_/Q _3768_/A2 _3767_/B1 _6889_/Q VGND VGND VPWR VPWR _3707_/X sky130_fd_sc_hd__a22o_2
XFILLER_104_9 VGND VGND VPWR VPWR sky130_fd_sc_hd__decap_3
XFILLER_108_24 VGND VGND VPWR VPWR sky130_fd_sc_hd__decap_3
XFILLER_108_35 VGND VGND VPWR VPWR sky130_fd_sc_hd__decap_3
X_6426_ _6616_/A VGND VGND VPWR VPWR _6426_/Y sky130_fd_sc_hd__inv_2
X_3638_ _3635_/A _3618_/C _3547_/A VGND VGND VPWR VPWR _3638_/X sky130_fd_sc_hd__a21bo_2
XFILLER_108_68 VGND VGND VPWR VPWR sky130_fd_sc_hd__decap_3
XFILLER_115_550 VGND VGND VPWR VPWR sky130_fd_sc_hd__decap_3
XFILLER_115_561 VGND VGND VPWR VPWR sky130_fd_sc_hd__decap_3
XFILLER_68_17 VGND VGND VPWR VPWR sky130_fd_sc_hd__decap_3
XFILLER_88_401 VGND VGND VPWR VPWR sky130_fd_sc_hd__decap_3
X_6357_ _6388_/A VGND VGND VPWR VPWR _6357_/Y sky130_fd_sc_hd__inv_2
X_3569_ _7285_/Q _5159_/S _3567_/X _3568_/X VGND VGND VPWR VPWR _3569_/X sky130_fd_sc_hd__a211o_2
XFILLER_0_327 VGND VGND VPWR VPWR sky130_fd_sc_hd__decap_3
XFILLER_115_594 VGND VGND VPWR VPWR sky130_fd_sc_hd__decap_3
X_5308_ _5308_/A0 _4822_/X _5315_/S VGND VGND VPWR VPWR _7176_/D sky130_fd_sc_hd__mux2_2
XFILLER_88_445 VGND VGND VPWR VPWR sky130_fd_sc_hd__decap_3
X_6288_ _6288_/A VGND VGND VPWR VPWR _6288_/Y sky130_fd_sc_hd__inv_2
XFILLER_102_277 VGND VGND VPWR VPWR sky130_fd_sc_hd__decap_3
XFILLER_48_309 VGND VGND VPWR VPWR sky130_fd_sc_hd__decap_3
X_5239_ hold967/X _5238_/X _4766_/A VGND VGND VPWR VPWR _7211_/D sky130_fd_sc_hd__a21o_2
XTAP_TAPCELL_ROW_110_1572 VGND VPWR sky130_fd_sc_hd__tapvpwrvgnd_1
XFILLER_84_38 VGND VGND VPWR VPWR sky130_fd_sc_hd__decap_3
XFILLER_84_640 VGND VGND VPWR VPWR sky130_fd_sc_hd__decap_3
XFILLER_16_206 VGND VGND VPWR VPWR sky130_fd_sc_hd__decap_3
XFILLER_17_21 VGND VGND VPWR VPWR sky130_fd_sc_hd__decap_3
XFILLER_29_556 VGND VGND VPWR VPWR sky130_fd_sc_hd__decap_3
XFILLER_29_567 VGND VGND VPWR VPWR sky130_fd_sc_hd__decap_3
XFILLER_29_578 VGND VGND VPWR VPWR sky130_fd_sc_hd__fill_2
XFILLER_84_651 VGND VGND VPWR VPWR sky130_fd_sc_hd__decap_3
XFILLER_56_386 VGND VGND VPWR VPWR sky130_fd_sc_hd__decap_3
XFILLER_71_301 VGND VGND VPWR VPWR sky130_fd_sc_hd__decap_3
XFILLER_84_684 VGND VGND VPWR VPWR sky130_fd_sc_hd__decap_3
XFILLER_17_87 VGND VGND VPWR VPWR sky130_fd_sc_hd__decap_3
XTAP_TAPCELL_ROW_14_418 VGND VPWR sky130_fd_sc_hd__tapvpwrvgnd_1
XFILLER_24_283 VGND VGND VPWR VPWR sky130_fd_sc_hd__decap_3
XFILLER_52_592 VGND VGND VPWR VPWR sky130_fd_sc_hd__decap_3
XFILLER_12_467 VGND VGND VPWR VPWR sky130_fd_sc_hd__fill_1
XFILLER_33_53 VGND VGND VPWR VPWR sky130_fd_sc_hd__decap_3
XFILLER_33_75 VGND VGND VPWR VPWR sky130_fd_sc_hd__decap_3
XFILLER_8_427 VGND VGND VPWR VPWR sky130_fd_sc_hd__decap_3
XFILLER_106_561 VGND VGND VPWR VPWR sky130_fd_sc_hd__decap_3
XFILLER_3_143 VGND VGND VPWR VPWR sky130_fd_sc_hd__decap_3
XFILLER_4_666 VGND VGND VPWR VPWR sky130_fd_sc_hd__decap_3
XFILLER_98_209 VGND VGND VPWR VPWR sky130_fd_sc_hd__fill_1
XFILLER_79_445 VGND VGND VPWR VPWR sky130_fd_sc_hd__decap_3
XFILLER_58_72 VGND VGND VPWR VPWR sky130_fd_sc_hd__decap_3
XFILLER_66_117 VGND VGND VPWR VPWR sky130_fd_sc_hd__decap_3
XFILLER_67_629 VGND VGND VPWR VPWR sky130_fd_sc_hd__decap_3
XFILLER_47_320 VGND VGND VPWR VPWR sky130_fd_sc_hd__decap_3
XFILLER_94_459 VGND VGND VPWR VPWR sky130_fd_sc_hd__decap_3
XFILLER_75_651 VGND VGND VPWR VPWR sky130_fd_sc_hd__decap_3
XFILLER_75_673 VGND VGND VPWR VPWR sky130_fd_sc_hd__decap_3
XFILLER_81_109 VGND VGND VPWR VPWR sky130_fd_sc_hd__decap_3
XFILLER_47_386 VGND VGND VPWR VPWR sky130_fd_sc_hd__decap_3
XFILLER_74_93 VGND VGND VPWR VPWR sky130_fd_sc_hd__fill_1
XFILLER_90_643 VGND VGND VPWR VPWR sky130_fd_sc_hd__fill_1
XFILLER_90_654 VGND VGND VPWR VPWR sky130_fd_sc_hd__decap_3
XFILLER_90_687 VGND VGND VPWR VPWR sky130_fd_sc_hd__decap_3
XFILLER_30_231 VGND VGND VPWR VPWR sky130_fd_sc_hd__fill_1
XFILLER_43_581 VGND VGND VPWR VPWR sky130_fd_sc_hd__decap_3
XFILLER_30_242 VGND VGND VPWR VPWR sky130_fd_sc_hd__decap_3
XFILLER_30_253 VGND VGND VPWR VPWR sky130_fd_sc_hd__decap_3
XFILLER_90_70 VGND VGND VPWR VPWR sky130_fd_sc_hd__decap_3
X_4610_ _4745_/A _4762_/B VGND VGND VPWR VPWR _4611_/A sky130_fd_sc_hd__nand2_2
X_7260_ _7294_/CLK _7260_/D _6540_/Y VGND VGND VPWR VPWR _7260_/Q sky130_fd_sc_hd__dfrtp_2
X_7191_ _7312_/CLK _7191_/D _6471_/Y VGND VGND VPWR VPWR _7191_/Q sky130_fd_sc_hd__dfrtp_2
X_3423_ _3442_/A _3442_/B _4289_/B VGND VGND VPWR VPWR _3424_/S sky130_fd_sc_hd__and3_4
XFILLER_99_90 VGND VGND VPWR VPWR sky130_fd_sc_hd__decap_3
XFILLER_112_542 VGND VGND VPWR VPWR sky130_fd_sc_hd__decap_3
XFILLER_58_607 VGND VGND VPWR VPWR sky130_fd_sc_hd__decap_3
X_3354_ _3327_/A _5668_/A _3328_/B _6983_/Q VGND VGND VPWR VPWR _3354_/X sky130_fd_sc_hd__a211o_2
XFILLER_112_575 VGND VGND VPWR VPWR sky130_fd_sc_hd__decap_3
XFILLER_57_106 VGND VGND VPWR VPWR sky130_fd_sc_hd__decap_3
XFILLER_85_404 VGND VGND VPWR VPWR sky130_fd_sc_hd__decap_3
Xhold1105 _7339_/Q VGND VGND VPWR VPWR _4480_/A0 sky130_fd_sc_hd__dlygate4sd3_1
XFILLER_38_320 VGND VGND VPWR VPWR sky130_fd_sc_hd__decap_3
XFILLER_66_640 VGND VGND VPWR VPWR sky130_fd_sc_hd__decap_3
Xhold1116 _7255_/Q VGND VGND VPWR VPWR _5108_/A0 sky130_fd_sc_hd__dlygate4sd3_1
Xhold1127 _7210_/Q VGND VGND VPWR VPWR _5240_/B2 sky130_fd_sc_hd__dlygate4sd3_1
Xhold1138 _7129_/Q VGND VGND VPWR VPWR _5409_/A0 sky130_fd_sc_hd__dlygate4sd3_1
Xhold1149 _7396_/Q VGND VGND VPWR VPWR _3757_/A0 sky130_fd_sc_hd__dlygate4sd3_1
X_5024_ _4832_/A _3832_/X _5015_/X _5023_/Y VGND VGND VPWR VPWR _5024_/X sky130_fd_sc_hd__a211o_2
XFILLER_66_651 VGND VGND VPWR VPWR sky130_fd_sc_hd__decap_3
XFILLER_38_397 VGND VGND VPWR VPWR sky130_fd_sc_hd__decap_3
XFILLER_53_301 VGND VGND VPWR VPWR sky130_fd_sc_hd__decap_3
XFILLER_65_172 VGND VGND VPWR VPWR sky130_fd_sc_hd__decap_3
XFILLER_66_684 VGND VGND VPWR VPWR sky130_fd_sc_hd__decap_3
XFILLER_81_610 VGND VGND VPWR VPWR sky130_fd_sc_hd__decap_3
XFILLER_81_632 VGND VGND VPWR VPWR sky130_fd_sc_hd__decap_3
XFILLER_53_334 VGND VGND VPWR VPWR sky130_fd_sc_hd__fill_2
XFILLER_80_120 VGND VGND VPWR VPWR sky130_fd_sc_hd__decap_3
XFILLER_81_665 VGND VGND VPWR VPWR sky130_fd_sc_hd__decap_3
X_6975_ _6975_/CLK _6975_/D VGND VGND VPWR VPWR _6975_/Q sky130_fd_sc_hd__dfxtp_2
XFILLER_80_175 VGND VGND VPWR VPWR sky130_fd_sc_hd__decap_3
XFILLER_81_676 VGND VGND VPWR VPWR sky130_fd_sc_hd__decap_3
XFILLER_110_47 VGND VGND VPWR VPWR sky130_fd_sc_hd__decap_3
XFILLER_21_220 VGND VGND VPWR VPWR sky130_fd_sc_hd__decap_3
XFILLER_80_197 VGND VGND VPWR VPWR sky130_fd_sc_hd__fill_1
XFILLER_21_231 VGND VGND VPWR VPWR sky130_fd_sc_hd__decap_3
XFILLER_70_18 VGND VGND VPWR VPWR sky130_fd_sc_hd__decap_3
XFILLER_70_29 VGND VGND VPWR VPWR sky130_fd_sc_hd__decap_3
XFILLER_21_275 VGND VGND VPWR VPWR sky130_fd_sc_hd__decap_3
XFILLER_5_408 VGND VGND VPWR VPWR sky130_fd_sc_hd__decap_3
X_4739_ _4762_/A _4762_/B _4765_/B _4745_/A VGND VGND VPWR VPWR _4739_/Y sky130_fd_sc_hd__a211oi_2
XFILLER_102_6 VGND VGND VPWR VPWR sky130_fd_sc_hd__decap_3
X_6409_ _6540_/A VGND VGND VPWR VPWR _6409_/Y sky130_fd_sc_hd__inv_2
XTAP_TAPCELL_ROW_112_1601 VGND VPWR sky130_fd_sc_hd__tapvpwrvgnd_1
XFILLER_1_603 VGND VGND VPWR VPWR sky130_fd_sc_hd__decap_3
XFILLER_1_625 VGND VGND VPWR VPWR sky130_fd_sc_hd__decap_3
X_7389_ _7390_/CLK _7389_/D _6669_/Y VGND VGND VPWR VPWR _7389_/Q sky130_fd_sc_hd__dfrtp_2
Xhold972 _6718_/Q VGND VGND VPWR VPWR hold972/X sky130_fd_sc_hd__dlygate4sd3_1
Xhold961 _6692_/Q VGND VGND VPWR VPWR hold961/X sky130_fd_sc_hd__dlygate4sd3_1
Xhold950 _6714_/Q VGND VGND VPWR VPWR hold950/X sky130_fd_sc_hd__dlygate4sd3_1
XFILLER_0_113 VGND VGND VPWR VPWR sky130_fd_sc_hd__decap_3
XFILLER_0_135 VGND VGND VPWR VPWR sky130_fd_sc_hd__decap_3
XFILLER_115_391 VGND VGND VPWR VPWR sky130_fd_sc_hd__fill_1
XFILLER_1_658 VGND VGND VPWR VPWR sky130_fd_sc_hd__decap_3
Xhold994 _7188_/Q VGND VGND VPWR VPWR hold994/X sky130_fd_sc_hd__dlygate4sd3_1
Xhold983 _7026_/Q VGND VGND VPWR VPWR _5602_/A sky130_fd_sc_hd__dlygate4sd3_1
XFILLER_103_564 VGND VGND VPWR VPWR sky130_fd_sc_hd__decap_3
XFILLER_48_117 VGND VGND VPWR VPWR sky130_fd_sc_hd__decap_3
XFILLER_49_629 VGND VGND VPWR VPWR sky130_fd_sc_hd__decap_3
XFILLER_88_253 VGND VGND VPWR VPWR sky130_fd_sc_hd__fill_1
XFILLER_95_15 VGND VGND VPWR VPWR sky130_fd_sc_hd__fill_1
XFILLER_95_37 VGND VGND VPWR VPWR sky130_fd_sc_hd__decap_3
XFILLER_76_448 VGND VGND VPWR VPWR sky130_fd_sc_hd__decap_3
XFILLER_28_64 VGND VGND VPWR VPWR sky130_fd_sc_hd__fill_2
XFILLER_57_662 VGND VGND VPWR VPWR sky130_fd_sc_hd__decap_3
XFILLER_57_673 VGND VGND VPWR VPWR sky130_fd_sc_hd__decap_3
XFILLER_91_418 VGND VGND VPWR VPWR sky130_fd_sc_hd__decap_3
XTAP_TAPCELL_ROW_47_819 VGND VPWR sky130_fd_sc_hd__tapvpwrvgnd_1
XFILLER_44_312 VGND VGND VPWR VPWR sky130_fd_sc_hd__fill_2
XFILLER_44_323 VGND VGND VPWR VPWR sky130_fd_sc_hd__decap_3
XFILLER_56_183 VGND VGND VPWR VPWR sky130_fd_sc_hd__decap_3
XFILLER_56_194 VGND VGND VPWR VPWR sky130_fd_sc_hd__fill_2
XFILLER_72_654 VGND VGND VPWR VPWR sky130_fd_sc_hd__decap_3
XPHY_EDGE_ROW_88_Left_205 VGND VGND VPWR VPWR sky130_fd_sc_hd__decap_3
XFILLER_32_518 VGND VGND VPWR VPWR sky130_fd_sc_hd__decap_3
XFILLER_44_52 VGND VGND VPWR VPWR sky130_fd_sc_hd__decap_3
XFILLER_71_153 VGND VGND VPWR VPWR sky130_fd_sc_hd__decap_3
XFILLER_72_687 VGND VGND VPWR VPWR sky130_fd_sc_hd__decap_3
XTAP_TAPCELL_ROW_27_576 VGND VPWR sky130_fd_sc_hd__tapvpwrvgnd_1
XFILLER_25_581 VGND VGND VPWR VPWR sky130_fd_sc_hd__decap_3
XFILLER_44_85 VGND VGND VPWR VPWR sky130_fd_sc_hd__decap_3
XFILLER_12_242 VGND VGND VPWR VPWR sky130_fd_sc_hd__decap_3
XFILLER_12_253 VGND VGND VPWR VPWR sky130_fd_sc_hd__decap_3
XFILLER_100_91 VGND VGND VPWR VPWR sky130_fd_sc_hd__decap_3
XFILLER_12_286 VGND VGND VPWR VPWR sky130_fd_sc_hd__decap_3
XFILLER_40_573 VGND VGND VPWR VPWR sky130_fd_sc_hd__decap_3
XFILLER_67_9 VGND VGND VPWR VPWR sky130_fd_sc_hd__decap_3
XPHY_EDGE_ROW_97_Left_214 VGND VGND VPWR VPWR sky130_fd_sc_hd__decap_3
XFILLER_4_430 VGND VGND VPWR VPWR sky130_fd_sc_hd__decap_3
XFILLER_5_24 VGND VGND VPWR VPWR sky130_fd_sc_hd__decap_3
XFILLER_5_57 VGND VGND VPWR VPWR sky130_fd_sc_hd__decap_3
XTAP_TAPCELL_ROW_74_1139 VGND VPWR sky130_fd_sc_hd__tapvpwrvgnd_1
XFILLER_106_380 VGND VGND VPWR VPWR sky130_fd_sc_hd__decap_3
XFILLER_69_60 VGND VGND VPWR VPWR sky130_fd_sc_hd__decap_3
XFILLER_69_93 VGND VGND VPWR VPWR sky130_fd_sc_hd__decap_3
XFILLER_79_231 VGND VGND VPWR VPWR sky130_fd_sc_hd__decap_3
XFILLER_94_223 VGND VGND VPWR VPWR sky130_fd_sc_hd__decap_3
XFILLER_48_640 VGND VGND VPWR VPWR sky130_fd_sc_hd__decap_3
XFILLER_48_651 VGND VGND VPWR VPWR sky130_fd_sc_hd__decap_3
XFILLER_54_109 VGND VGND VPWR VPWR sky130_fd_sc_hd__decap_3
XFILLER_85_70 VGND VGND VPWR VPWR sky130_fd_sc_hd__decap_3
XFILLER_35_301 VGND VGND VPWR VPWR sky130_fd_sc_hd__decap_3
XFILLER_63_610 VGND VGND VPWR VPWR sky130_fd_sc_hd__decap_3
XFILLER_63_632 VGND VGND VPWR VPWR sky130_fd_sc_hd__decap_3
XFILLER_75_481 VGND VGND VPWR VPWR sky130_fd_sc_hd__fill_2
XFILLER_94_289 VGND VGND VPWR VPWR sky130_fd_sc_hd__decap_3
XFILLER_62_131 VGND VGND VPWR VPWR sky130_fd_sc_hd__fill_1
XFILLER_63_665 VGND VGND VPWR VPWR sky130_fd_sc_hd__decap_3
XFILLER_35_367 VGND VGND VPWR VPWR sky130_fd_sc_hd__decap_3
XFILLER_35_389 VGND VGND VPWR VPWR sky130_fd_sc_hd__decap_3
XFILLER_62_153 VGND VGND VPWR VPWR sky130_fd_sc_hd__decap_3
XFILLER_62_175 VGND VGND VPWR VPWR sky130_fd_sc_hd__decap_3
XFILLER_63_676 VGND VGND VPWR VPWR sky130_fd_sc_hd__decap_3
X_6760_ _6976_/CLK _6760_/D VGND VGND VPWR VPWR _6760_/Q sky130_fd_sc_hd__dfxtp_2
XTAP_TAPCELL_ROW_85_1268 VGND VPWR sky130_fd_sc_hd__tapvpwrvgnd_1
XFILLER_16_581 VGND VGND VPWR VPWR sky130_fd_sc_hd__decap_3
XFILLER_16_592 VGND VGND VPWR VPWR sky130_fd_sc_hd__decap_3
XFILLER_50_326 VGND VGND VPWR VPWR sky130_fd_sc_hd__decap_3
XFILLER_62_186 VGND VGND VPWR VPWR sky130_fd_sc_hd__decap_3
XFILLER_62_197 VGND VGND VPWR VPWR sky130_fd_sc_hd__decap_3
X_6691_ clkload2/A _6691_/D VGND VGND VPWR VPWR _6691_/Q sky130_fd_sc_hd__dfxtp_2
X_5642_ _5642_/A _5642_/B VGND VGND VPWR VPWR _5643_/A sky130_fd_sc_hd__or2_2
X_5573_ hold990/X _5015_/A _4975_/Y VGND VGND VPWR VPWR _7044_/D sky130_fd_sc_hd__o21a_2
XFILLER_116_100 VGND VGND VPWR VPWR sky130_fd_sc_hd__decap_3
X_7312_ _7312_/CLK _7312_/D _6592_/Y VGND VGND VPWR VPWR _7312_/Q sky130_fd_sc_hd__dfrtp_2
X_4524_ _4524_/A0 _7285_/Q _4528_/B VGND VGND VPWR VPWR _7317_/D sky130_fd_sc_hd__mux2_2
XFILLER_116_144 VGND VGND VPWR VPWR sky130_fd_sc_hd__decap_3
XFILLER_104_306 VGND VGND VPWR VPWR sky130_fd_sc_hd__fill_2
X_7243_ _7372_/CLK _7243_/D _6523_/Y VGND VGND VPWR VPWR _7243_/Q sky130_fd_sc_hd__dfrtp_2
X_4455_ _4069_/Y _4081_/X _4082_/X _4454_/X VGND VGND VPWR VPWR _4720_/B sky130_fd_sc_hd__o211a_2
XFILLER_104_339 VGND VGND VPWR VPWR sky130_fd_sc_hd__decap_3
X_7174_ _7334_/CLK _7174_/D _6454_/Y VGND VGND VPWR VPWR _7174_/Q sky130_fd_sc_hd__dfrtp_2
X_4386_ _7305_/Q _4482_/S _4429_/B1 _7369_/Q _4429_/C1 VGND VGND VPWR VPWR _4386_/X
+ sky130_fd_sc_hd__a221o_2
X_3406_ _3409_/D VGND VGND VPWR VPWR _3417_/C sky130_fd_sc_hd__inv_4
XFILLER_100_545 VGND VGND VPWR VPWR sky130_fd_sc_hd__decap_3
XFILLER_105_36 VGND VGND VPWR VPWR sky130_fd_sc_hd__decap_3
XFILLER_85_234 VGND VGND VPWR VPWR sky130_fd_sc_hd__fill_2
XFILLER_65_18 VGND VGND VPWR VPWR sky130_fd_sc_hd__decap_3
XFILLER_26_312 VGND VGND VPWR VPWR sky130_fd_sc_hd__decap_3
XFILLER_39_673 VGND VGND VPWR VPWR sky130_fd_sc_hd__decap_3
XFILLER_54_610 VGND VGND VPWR VPWR sky130_fd_sc_hd__decap_3
XFILLER_66_470 VGND VGND VPWR VPWR sky130_fd_sc_hd__decap_3
X_5007_ _5002_/Y _5003_/X _5004_/X _5005_/Y _5006_/X VGND VGND VPWR VPWR _5662_/A
+ sky130_fd_sc_hd__a221o_2
XFILLER_26_334 VGND VGND VPWR VPWR sky130_fd_sc_hd__decap_3
XFILLER_38_194 VGND VGND VPWR VPWR sky130_fd_sc_hd__fill_2
XFILLER_54_643 VGND VGND VPWR VPWR sky130_fd_sc_hd__fill_1
XFILLER_54_654 VGND VGND VPWR VPWR sky130_fd_sc_hd__decap_3
XFILLER_14_507 VGND VGND VPWR VPWR sky130_fd_sc_hd__decap_3
XFILLER_41_304 VGND VGND VPWR VPWR sky130_fd_sc_hd__decap_3
XFILLER_53_175 VGND VGND VPWR VPWR sky130_fd_sc_hd__decap_3
XFILLER_54_687 VGND VGND VPWR VPWR sky130_fd_sc_hd__decap_3
XFILLER_41_337 VGND VGND VPWR VPWR sky130_fd_sc_hd__fill_2
XFILLER_53_197 VGND VGND VPWR VPWR sky130_fd_sc_hd__decap_3
XFILLER_81_39 VGND VGND VPWR VPWR sky130_fd_sc_hd__decap_3
X_6958_ _6972_/CLK _6958_/D VGND VGND VPWR VPWR _6958_/Q sky130_fd_sc_hd__dfxtp_2
XTAP_TAPCELL_ROW_24_535 VGND VPWR sky130_fd_sc_hd__tapvpwrvgnd_1
XFILLER_14_44 VGND VGND VPWR VPWR sky130_fd_sc_hd__decap_3
X_6889_ _7406_/CLK _6889_/D VGND VGND VPWR VPWR _6889_/Q sky130_fd_sc_hd__dfxtp_2
XTAP_TAPCELL_ROW_52_877 VGND VPWR sky130_fd_sc_hd__tapvpwrvgnd_1
XFILLER_14_77 VGND VGND VPWR VPWR sky130_fd_sc_hd__decap_3
XFILLER_108_601 VGND VGND VPWR VPWR sky130_fd_sc_hd__decap_3
XFILLER_107_111 VGND VGND VPWR VPWR sky130_fd_sc_hd__fill_1
XFILLER_108_634 VGND VGND VPWR VPWR sky130_fd_sc_hd__decap_3
XFILLER_108_645 VGND VGND VPWR VPWR sky130_fd_sc_hd__decap_3
XFILLER_30_32 VGND VGND VPWR VPWR sky130_fd_sc_hd__decap_3
XFILLER_107_122 VGND VGND VPWR VPWR sky130_fd_sc_hd__decap_3
XFILLER_108_678 VGND VGND VPWR VPWR sky130_fd_sc_hd__decap_3
XFILLER_30_65 VGND VGND VPWR VPWR sky130_fd_sc_hd__decap_3
XFILLER_5_249 VGND VGND VPWR VPWR sky130_fd_sc_hd__decap_3
XFILLER_100_3 VGND VGND VPWR VPWR sky130_fd_sc_hd__decap_3
XFILLER_107_199 VGND VGND VPWR VPWR sky130_fd_sc_hd__decap_3
XFILLER_1_411 VGND VGND VPWR VPWR sky130_fd_sc_hd__decap_3
XFILLER_1_444 VGND VGND VPWR VPWR sky130_fd_sc_hd__decap_3
Xhold780 _6762_/Q VGND VGND VPWR VPWR _6762_/D sky130_fd_sc_hd__dlygate4sd3_1
Xhold791 _6755_/Q VGND VGND VPWR VPWR _6755_/D sky130_fd_sc_hd__dlygate4sd3_1
XFILLER_1_455 VGND VGND VPWR VPWR sky130_fd_sc_hd__decap_3
XFILLER_49_437 VGND VGND VPWR VPWR sky130_fd_sc_hd__decap_3
XFILLER_76_234 VGND VGND VPWR VPWR sky130_fd_sc_hd__decap_3
XFILLER_39_85 VGND VGND VPWR VPWR sky130_fd_sc_hd__fill_2
XFILLER_76_245 VGND VGND VPWR VPWR sky130_fd_sc_hd__decap_3
XFILLER_29_172 VGND VGND VPWR VPWR sky130_fd_sc_hd__fill_1
XFILLER_17_323 VGND VGND VPWR VPWR sky130_fd_sc_hd__fill_1
XFILLER_45_632 VGND VGND VPWR VPWR sky130_fd_sc_hd__fill_1
XFILLER_91_248 VGND VGND VPWR VPWR sky130_fd_sc_hd__decap_3
XFILLER_91_259 VGND VGND VPWR VPWR sky130_fd_sc_hd__decap_3
XFILLER_45_676 VGND VGND VPWR VPWR sky130_fd_sc_hd__decap_3
XFILLER_55_84 VGND VGND VPWR VPWR sky130_fd_sc_hd__decap_3
XFILLER_60_613 VGND VGND VPWR VPWR sky130_fd_sc_hd__decap_3
XFILLER_72_462 VGND VGND VPWR VPWR sky130_fd_sc_hd__decap_3
XFILLER_32_315 VGND VGND VPWR VPWR sky130_fd_sc_hd__decap_3
XFILLER_60_657 VGND VGND VPWR VPWR sky130_fd_sc_hd__decap_3
XFILLER_111_90 VGND VGND VPWR VPWR sky130_fd_sc_hd__decap_3
XFILLER_13_540 VGND VGND VPWR VPWR sky130_fd_sc_hd__decap_3
XFILLER_71_50 VGND VGND VPWR VPWR sky130_fd_sc_hd__decap_3
XFILLER_9_500 VGND VGND VPWR VPWR sky130_fd_sc_hd__decap_3
XFILLER_9_522 VGND VGND VPWR VPWR sky130_fd_sc_hd__fill_1
XFILLER_65_6 VGND VGND VPWR VPWR sky130_fd_sc_hd__decap_3
XFILLER_114_604 VGND VGND VPWR VPWR sky130_fd_sc_hd__decap_3
XFILLER_114_637 VGND VGND VPWR VPWR sky130_fd_sc_hd__decap_3
XFILLER_113_125 VGND VGND VPWR VPWR sky130_fd_sc_hd__decap_3
XFILLER_114_648 VGND VGND VPWR VPWR sky130_fd_sc_hd__decap_3
XFILLER_4_271 VGND VGND VPWR VPWR sky130_fd_sc_hd__decap_3
X_4240_ _4628_/A _4629_/B VGND VGND VPWR VPWR _4241_/B sky130_fd_sc_hd__and2_2
XFILLER_113_158 VGND VGND VPWR VPWR sky130_fd_sc_hd__decap_3
XFILLER_113_169 VGND VGND VPWR VPWR sky130_fd_sc_hd__decap_3
X_4171_ _4203_/A _4203_/B _4202_/A VGND VGND VPWR VPWR _4379_/B sky130_fd_sc_hd__a21oi_2
XFILLER_67_223 VGND VGND VPWR VPWR sky130_fd_sc_hd__fill_1
XFILLER_67_234 VGND VGND VPWR VPWR sky130_fd_sc_hd__fill_1
XFILLER_95_543 VGND VGND VPWR VPWR sky130_fd_sc_hd__decap_3
XFILLER_67_267 VGND VGND VPWR VPWR sky130_fd_sc_hd__decap_3
XFILLER_96_91 VGND VGND VPWR VPWR sky130_fd_sc_hd__decap_3
XFILLER_36_621 VGND VGND VPWR VPWR sky130_fd_sc_hd__fill_2
XFILLER_55_418 VGND VGND VPWR VPWR sky130_fd_sc_hd__fill_2
XFILLER_82_215 VGND VGND VPWR VPWR sky130_fd_sc_hd__decap_3
XFILLER_35_131 VGND VGND VPWR VPWR sky130_fd_sc_hd__decap_3
XFILLER_82_248 VGND VGND VPWR VPWR sky130_fd_sc_hd__decap_3
XFILLER_82_259 VGND VGND VPWR VPWR sky130_fd_sc_hd__decap_3
XFILLER_23_304 VGND VGND VPWR VPWR sky130_fd_sc_hd__decap_3
XFILLER_51_602 VGND VGND VPWR VPWR sky130_fd_sc_hd__decap_3
XFILLER_63_473 VGND VGND VPWR VPWR sky130_fd_sc_hd__decap_3
Xplace440 _5570_/A2 VGND VGND VPWR VPWR _4983_/A sky130_fd_sc_hd__buf_2
X_6812_ _6970_/CLK _6812_/D VGND VGND VPWR VPWR _6812_/Q sky130_fd_sc_hd__dfxtp_2
XFILLER_23_315 VGND VGND VPWR VPWR sky130_fd_sc_hd__decap_3
XFILLER_23_337 VGND VGND VPWR VPWR sky130_fd_sc_hd__decap_3
XFILLER_50_123 VGND VGND VPWR VPWR sky130_fd_sc_hd__decap_3
XFILLER_51_635 VGND VGND VPWR VPWR sky130_fd_sc_hd__decap_3
XFILLER_90_292 VGND VGND VPWR VPWR sky130_fd_sc_hd__decap_3
Xplace451 _7002_/Q VGND VGND VPWR VPWR place451/X sky130_fd_sc_hd__buf_2
Xplace462 _6979_/Q VGND VGND VPWR VPWR _3362_/A sky130_fd_sc_hd__buf_2
XFILLER_23_359 VGND VGND VPWR VPWR sky130_fd_sc_hd__decap_3
XFILLER_51_668 VGND VGND VPWR VPWR sky130_fd_sc_hd__decap_3
XFILLER_51_679 VGND VGND VPWR VPWR sky130_fd_sc_hd__decap_3
X_6743_ _6965_/CLK _6743_/D VGND VGND VPWR VPWR _6743_/Q sky130_fd_sc_hd__dfxtp_2
XFILLER_50_167 VGND VGND VPWR VPWR sky130_fd_sc_hd__decap_3
X_6674_ _6674_/A VGND VGND VPWR VPWR _6674_/Y sky130_fd_sc_hd__inv_2
XTAP_TAPCELL_ROW_21_505 VGND VPWR sky130_fd_sc_hd__tapvpwrvgnd_1
X_3886_ _6920_/Q _3886_/A2 _3886_/B1 _6784_/Q VGND VGND VPWR VPWR _3886_/X sky130_fd_sc_hd__a22o_2
XTAP_TAPCELL_ROW_98_1426 VGND VPWR sky130_fd_sc_hd__tapvpwrvgnd_1
XFILLER_104_103 VGND VGND VPWR VPWR sky130_fd_sc_hd__decap_3
XFILLER_105_604 VGND VGND VPWR VPWR sky130_fd_sc_hd__decap_3
XFILLER_105_626 VGND VGND VPWR VPWR sky130_fd_sc_hd__decap_3
X_4507_ _4507_/A0 _4573_/A _4517_/S VGND VGND VPWR VPWR _7326_/D sky130_fd_sc_hd__mux2_2
XFILLER_104_125 VGND VGND VPWR VPWR sky130_fd_sc_hd__decap_3
XFILLER_104_147 VGND VGND VPWR VPWR sky130_fd_sc_hd__decap_3
XFILLER_105_659 VGND VGND VPWR VPWR sky130_fd_sc_hd__decap_3
X_7226_ clkload8/A _7226_/D _6506_/Y VGND VGND VPWR VPWR _7226_/Q sky130_fd_sc_hd__dfrtp_2
X_4438_ _4434_/X _4437_/X _4425_/A VGND VGND VPWR VPWR _4650_/B sky130_fd_sc_hd__o21a_2
XFILLER_116_35 VGND VGND VPWR VPWR sky130_fd_sc_hd__decap_3
XFILLER_116_68 VGND VGND VPWR VPWR sky130_fd_sc_hd__decap_3
XFILLER_58_212 VGND VGND VPWR VPWR sky130_fd_sc_hd__decap_3
XFILLER_86_510 VGND VGND VPWR VPWR sky130_fd_sc_hd__decap_3
X_7157_ clkload4/A _7157_/D _6437_/Y VGND VGND VPWR VPWR _7157_/Q sky130_fd_sc_hd__dfrtp_2
X_4369_ _4369_/A _4369_/B VGND VGND VPWR VPWR _4369_/Y sky130_fd_sc_hd__nor2_2
XFILLER_112_180 VGND VGND VPWR VPWR sky130_fd_sc_hd__decap_3
X_7088_ clkload4/A _7088_/D _6368_/Y VGND VGND VPWR VPWR _7088_/Q sky130_fd_sc_hd__dfrtp_2
XFILLER_100_386 VGND VGND VPWR VPWR sky130_fd_sc_hd__decap_3
XFILLER_46_418 VGND VGND VPWR VPWR sky130_fd_sc_hd__fill_2
XFILLER_73_204 VGND VGND VPWR VPWR sky130_fd_sc_hd__decap_3
XFILLER_86_587 VGND VGND VPWR VPWR sky130_fd_sc_hd__fill_1
XTAP_TAPCELL_ROW_57_936 VGND VPWR sky130_fd_sc_hd__tapvpwrvgnd_1
XTAP_TAPCELL_ROW_29_605 VGND VPWR sky130_fd_sc_hd__tapvpwrvgnd_1
XFILLER_26_120 VGND VGND VPWR VPWR sky130_fd_sc_hd__decap_3
XFILLER_39_492 VGND VGND VPWR VPWR sky130_fd_sc_hd__fill_1
XFILLER_73_248 VGND VGND VPWR VPWR sky130_fd_sc_hd__decap_3
XTAP_TAPCELL_ROW_107_1533 VGND VPWR sky130_fd_sc_hd__tapvpwrvgnd_1
XFILLER_54_440 VGND VGND VPWR VPWR sky130_fd_sc_hd__fill_1
XFILLER_54_473 VGND VGND VPWR VPWR sky130_fd_sc_hd__decap_3
XFILLER_92_38 VGND VGND VPWR VPWR sky130_fd_sc_hd__decap_3
XTAP_TAPCELL_ROW_1_263 VGND VPWR sky130_fd_sc_hd__tapvpwrvgnd_1
XFILLER_26_197 VGND VGND VPWR VPWR sky130_fd_sc_hd__decap_3
XFILLER_42_624 VGND VGND VPWR VPWR sky130_fd_sc_hd__fill_1
XFILLER_81_281 VGND VGND VPWR VPWR sky130_fd_sc_hd__decap_3
XTAP_TAPCELL_ROW_37_693 VGND VPWR sky130_fd_sc_hd__tapvpwrvgnd_1
XFILLER_41_145 VGND VGND VPWR VPWR sky130_fd_sc_hd__fill_2
XFILLER_42_668 VGND VGND VPWR VPWR sky130_fd_sc_hd__decap_3
XFILLER_41_189 VGND VGND VPWR VPWR sky130_fd_sc_hd__decap_3
XFILLER_41_20 VGND VGND VPWR VPWR sky130_fd_sc_hd__decap_3
XFILLER_50_690 VGND VGND VPWR VPWR sky130_fd_sc_hd__fill_2
XFILLER_41_53 VGND VGND VPWR VPWR sky130_fd_sc_hd__decap_3
XFILLER_41_75 VGND VGND VPWR VPWR sky130_fd_sc_hd__decap_3
XFILLER_108_475 VGND VGND VPWR VPWR sky130_fd_sc_hd__fill_1
XTAP_TAPCELL_ROW_71_1109 VGND VPWR sky130_fd_sc_hd__tapvpwrvgnd_1
XFILLER_111_629 VGND VGND VPWR VPWR sky130_fd_sc_hd__decap_3
XTAP_TAPCELL_ROW_9_363 VGND VPWR sky130_fd_sc_hd__tapvpwrvgnd_1
XFILLER_104_681 VGND VGND VPWR VPWR sky130_fd_sc_hd__decap_3
XFILLER_110_106 VGND VGND VPWR VPWR sky130_fd_sc_hd__decap_3
XFILLER_110_139 VGND VGND VPWR VPWR sky130_fd_sc_hd__fill_1
XFILLER_2_14 VGND VGND VPWR VPWR sky130_fd_sc_hd__decap_3
XFILLER_49_212 VGND VGND VPWR VPWR sky130_fd_sc_hd__decap_3
XFILLER_103_180 VGND VGND VPWR VPWR sky130_fd_sc_hd__fill_2
XFILLER_2_47 VGND VGND VPWR VPWR sky130_fd_sc_hd__decap_3
XFILLER_49_245 VGND VGND VPWR VPWR sky130_fd_sc_hd__decap_3
XFILLER_49_267 VGND VGND VPWR VPWR sky130_fd_sc_hd__decap_3
XFILLER_49_278 VGND VGND VPWR VPWR sky130_fd_sc_hd__fill_2
XFILLER_49_289 VGND VGND VPWR VPWR sky130_fd_sc_hd__decap_3
XFILLER_66_72 VGND VGND VPWR VPWR sky130_fd_sc_hd__decap_3
XFILLER_18_643 VGND VGND VPWR VPWR sky130_fd_sc_hd__fill_1
XFILLER_64_259 VGND VGND VPWR VPWR sky130_fd_sc_hd__decap_3
XFILLER_17_175 VGND VGND VPWR VPWR sky130_fd_sc_hd__fill_1
XFILLER_17_197 VGND VGND VPWR VPWR sky130_fd_sc_hd__decap_3
XFILLER_60_421 VGND VGND VPWR VPWR sky130_fd_sc_hd__decap_3
XTAP_TAPCELL_ROW_82_1238 VGND VPWR sky130_fd_sc_hd__tapvpwrvgnd_1
XFILLER_33_668 VGND VGND VPWR VPWR sky130_fd_sc_hd__decap_3
XFILLER_82_71 VGND VGND VPWR VPWR sky130_fd_sc_hd__decap_3
XFILLER_82_93 VGND VGND VPWR VPWR sky130_fd_sc_hd__decap_3
X_3740_ _6710_/Q _3887_/A2 _3912_/B1 _6888_/Q _3739_/X VGND VGND VPWR VPWR _3740_/X
+ sky130_fd_sc_hd__a221o_2
XFILLER_9_352 VGND VGND VPWR VPWR sky130_fd_sc_hd__decap_3
X_3671_ _3671_/A1 _4832_/A _3670_/X VGND VGND VPWR VPWR _7405_/D sky130_fd_sc_hd__o21a_2
XFILLER_9_385 VGND VGND VPWR VPWR sky130_fd_sc_hd__decap_3
X_6390_ _6616_/A VGND VGND VPWR VPWR _6390_/Y sky130_fd_sc_hd__inv_2
XTAP_TAPCELL_ROW_93_1367 VGND VPWR sky130_fd_sc_hd__tapvpwrvgnd_1
XFILLER_102_618 VGND VGND VPWR VPWR sky130_fd_sc_hd__decap_3
X_7011_ clkload8/A _7011_/D _6291_/Y VGND VGND VPWR VPWR _7011_/Q sky130_fd_sc_hd__dfrtp_2
X_5272_ _5272_/A0 _5061_/X _5274_/S VGND VGND VPWR VPWR _7194_/D sky130_fd_sc_hd__mux2_2
XFILLER_99_156 VGND VGND VPWR VPWR sky130_fd_sc_hd__decap_3
X_4223_ _4217_/X _4219_/X _4222_/X _4327_/A VGND VGND VPWR VPWR _4224_/C sky130_fd_sc_hd__o31a_2
XFILLER_101_139 VGND VGND VPWR VPWR sky130_fd_sc_hd__decap_3
XFILLER_110_640 VGND VGND VPWR VPWR sky130_fd_sc_hd__decap_3
XFILLER_110_651 VGND VGND VPWR VPWR sky130_fd_sc_hd__decap_3
XFILLER_95_340 VGND VGND VPWR VPWR sky130_fd_sc_hd__decap_3
X_4154_ _7047_/Q _4505_/S _4429_/B1 _7394_/Q _4153_/X VGND VGND VPWR VPWR _4154_/X
+ sky130_fd_sc_hd__a221o_2
XFILLER_110_684 VGND VGND VPWR VPWR sky130_fd_sc_hd__decap_3
XFILLER_28_407 VGND VGND VPWR VPWR sky130_fd_sc_hd__decap_3
XFILLER_55_204 VGND VGND VPWR VPWR sky130_fd_sc_hd__decap_3
XFILLER_95_362 VGND VGND VPWR VPWR sky130_fd_sc_hd__decap_3
X_4085_ _7238_/Q _4430_/A2 _5229_/C _7142_/Q _4084_/X VGND VGND VPWR VPWR _4085_/X
+ sky130_fd_sc_hd__a221o_2
XFILLER_55_248 VGND VGND VPWR VPWR sky130_fd_sc_hd__decap_3
XFILLER_102_15 VGND VGND VPWR VPWR sky130_fd_sc_hd__decap_3
XFILLER_36_451 VGND VGND VPWR VPWR sky130_fd_sc_hd__fill_2
XFILLER_63_270 VGND VGND VPWR VPWR sky130_fd_sc_hd__decap_3
XFILLER_63_281 VGND VGND VPWR VPWR sky130_fd_sc_hd__decap_3
XFILLER_23_145 VGND VGND VPWR VPWR sky130_fd_sc_hd__fill_1
Xplace281 _3656_/Y VGND VGND VPWR VPWR _3893_/B1 sky130_fd_sc_hd__buf_2
Xplace270 _3665_/X VGND VGND VPWR VPWR _3883_/B1 sky130_fd_sc_hd__buf_2
XFILLER_23_178 VGND VGND VPWR VPWR sky130_fd_sc_hd__decap_3
Xplace292 _3862_/B1 VGND VGND VPWR VPWR _3759_/A2 sky130_fd_sc_hd__buf_2
X_6726_ _6909_/CLK _6726_/D VGND VGND VPWR VPWR _6726_/Q sky130_fd_sc_hd__dfxtp_2
X_4987_ _4987_/A _4987_/B VGND VGND VPWR VPWR _4987_/Y sky130_fd_sc_hd__xnor2_2
XTAP_TAPCELL_ROW_62_994 VGND VPWR sky130_fd_sc_hd__tapvpwrvgnd_1
XTAP_TAPCELL_ROW_34_663 VGND VPWR sky130_fd_sc_hd__tapvpwrvgnd_1
XFILLER_32_690 VGND VGND VPWR VPWR sky130_fd_sc_hd__fill_2
XTAP_TAPCELL_ROW_102_1474 VGND VPWR sky130_fd_sc_hd__tapvpwrvgnd_1
X_6657_ _6660_/A VGND VGND VPWR VPWR _6657_/Y sky130_fd_sc_hd__inv_2
X_3869_ _6772_/Q _3902_/A2 _3912_/B1 _6766_/Q VGND VGND VPWR VPWR _3869_/X sky130_fd_sc_hd__a22o_2
XFILLER_11_12 VGND VGND VPWR VPWR sky130_fd_sc_hd__decap_3
X_6588_ _6651_/A VGND VGND VPWR VPWR _6588_/Y sky130_fd_sc_hd__inv_2
XFILLER_11_45 VGND VGND VPWR VPWR sky130_fd_sc_hd__decap_3
XFILLER_105_434 VGND VGND VPWR VPWR sky130_fd_sc_hd__decap_3
XFILLER_11_78 VGND VGND VPWR VPWR sky130_fd_sc_hd__decap_3
XFILLER_78_318 VGND VGND VPWR VPWR sky130_fd_sc_hd__decap_3
XFILLER_87_27 VGND VGND VPWR VPWR sky130_fd_sc_hd__decap_3
XPHY_EDGE_ROW_52_Left_169 VGND VGND VPWR VPWR sky130_fd_sc_hd__decap_3
X_7209_ _7337_/CLK _7209_/D _6489_/Y VGND VGND VPWR VPWR _7209_/Q sky130_fd_sc_hd__dfrtp_2
XTAP_TAPCELL_ROW_6_322 VGND VPWR sky130_fd_sc_hd__tapvpwrvgnd_1
XFILLER_101_662 VGND VGND VPWR VPWR sky130_fd_sc_hd__decap_3
XFILLER_101_673 VGND VGND VPWR VPWR sky130_fd_sc_hd__decap_3
XFILLER_46_215 VGND VGND VPWR VPWR sky130_fd_sc_hd__decap_3
XFILLER_59_587 VGND VGND VPWR VPWR sky130_fd_sc_hd__decap_3
XFILLER_74_524 VGND VGND VPWR VPWR sky130_fd_sc_hd__decap_3
XFILLER_86_362 VGND VGND VPWR VPWR sky130_fd_sc_hd__fill_2
XFILLER_100_194 VGND VGND VPWR VPWR sky130_fd_sc_hd__fill_2
XFILLER_46_248 VGND VGND VPWR VPWR sky130_fd_sc_hd__decap_3
XFILLER_86_395 VGND VGND VPWR VPWR sky130_fd_sc_hd__decap_3
XFILLER_46_259 VGND VGND VPWR VPWR sky130_fd_sc_hd__decap_3
XFILLER_74_568 VGND VGND VPWR VPWR sky130_fd_sc_hd__fill_1
XFILLER_15_613 VGND VGND VPWR VPWR sky130_fd_sc_hd__decap_3
XFILLER_42_410 VGND VGND VPWR VPWR sky130_fd_sc_hd__decap_3
XFILLER_54_281 VGND VGND VPWR VPWR sky130_fd_sc_hd__decap_3
XTAP_TAPCELL_ROW_68_1071 VGND VPWR sky130_fd_sc_hd__tapvpwrvgnd_1
XPHY_EDGE_ROW_61_Left_178 VGND VGND VPWR VPWR sky130_fd_sc_hd__decap_3
XFILLER_14_123 VGND VGND VPWR VPWR sky130_fd_sc_hd__decap_3
XFILLER_42_432 VGND VGND VPWR VPWR sky130_fd_sc_hd__decap_3
XFILLER_42_454 VGND VGND VPWR VPWR sky130_fd_sc_hd__decap_3
XFILLER_30_638 VGND VGND VPWR VPWR sky130_fd_sc_hd__decap_3
XFILLER_52_41 VGND VGND VPWR VPWR sky130_fd_sc_hd__decap_3
XFILLER_52_74 VGND VGND VPWR VPWR sky130_fd_sc_hd__fill_1
XFILLER_52_85 VGND VGND VPWR VPWR sky130_fd_sc_hd__decap_3
XPHY_EDGE_ROW_70_Left_187 VGND VGND VPWR VPWR sky130_fd_sc_hd__decap_3
XFILLER_6_399 VGND VGND VPWR VPWR sky130_fd_sc_hd__decap_3
XFILLER_2_561 VGND VGND VPWR VPWR sky130_fd_sc_hd__decap_3
XFILLER_2_583 VGND VGND VPWR VPWR sky130_fd_sc_hd__decap_3
XFILLER_96_115 VGND VGND VPWR VPWR sky130_fd_sc_hd__decap_3
XFILLER_97_638 VGND VGND VPWR VPWR sky130_fd_sc_hd__decap_3
XFILLER_28_6 VGND VGND VPWR VPWR sky130_fd_sc_hd__decap_3
XFILLER_77_340 VGND VGND VPWR VPWR sky130_fd_sc_hd__fill_2
XFILLER_77_60 VGND VGND VPWR VPWR sky130_fd_sc_hd__decap_3
XFILLER_77_82 VGND VGND VPWR VPWR sky130_fd_sc_hd__decap_3
XFILLER_37_204 VGND VGND VPWR VPWR sky130_fd_sc_hd__decap_3
XFILLER_77_373 VGND VGND VPWR VPWR sky130_fd_sc_hd__decap_3
XFILLER_37_248 VGND VGND VPWR VPWR sky130_fd_sc_hd__decap_3
XFILLER_65_557 VGND VGND VPWR VPWR sky130_fd_sc_hd__decap_3
XFILLER_92_332 VGND VGND VPWR VPWR sky130_fd_sc_hd__decap_3
XFILLER_18_451 VGND VGND VPWR VPWR sky130_fd_sc_hd__decap_3
XFILLER_52_207 VGND VGND VPWR VPWR sky130_fd_sc_hd__fill_2
XFILLER_80_516 VGND VGND VPWR VPWR sky130_fd_sc_hd__decap_3
XFILLER_45_281 VGND VGND VPWR VPWR sky130_fd_sc_hd__decap_3
XFILLER_52_229 VGND VGND VPWR VPWR sky130_fd_sc_hd__decap_3
XFILLER_92_398 VGND VGND VPWR VPWR sky130_fd_sc_hd__decap_3
X_4910_ _5092_/C _4910_/B VGND VGND VPWR VPWR _4910_/Y sky130_fd_sc_hd__nand2_2
X_4841_ _4890_/B _4888_/B VGND VGND VPWR VPWR _4841_/Y sky130_fd_sc_hd__nand2b_2
XFILLER_33_465 VGND VGND VPWR VPWR sky130_fd_sc_hd__decap_3
XFILLER_60_262 VGND VGND VPWR VPWR sky130_fd_sc_hd__decap_3
XFILLER_20_126 VGND VGND VPWR VPWR sky130_fd_sc_hd__decap_3
XFILLER_20_137 VGND VGND VPWR VPWR sky130_fd_sc_hd__decap_3
X_4772_ _4772_/A0 _4771_/X _4837_/S VGND VGND VPWR VPWR _7275_/D sky130_fd_sc_hd__mux2_2
XTAP_TAPCELL_ROW_31_622 VGND VPWR sky130_fd_sc_hd__tapvpwrvgnd_1
X_6511_ _6548_/A VGND VGND VPWR VPWR _6511_/Y sky130_fd_sc_hd__inv_2
X_3723_ _6813_/Q _3884_/B1 _3888_/B1 _6823_/Q VGND VGND VPWR VPWR _3723_/X sky130_fd_sc_hd__a22o_2
X_6442_ _6535_/A VGND VGND VPWR VPWR _6442_/Y sky130_fd_sc_hd__inv_2
XFILLER_106_209 VGND VGND VPWR VPWR sky130_fd_sc_hd__fill_2
X_6373_ _6567_/A VGND VGND VPWR VPWR _6373_/Y sky130_fd_sc_hd__inv_2
X_3585_ _3591_/A _3591_/B _3591_/C _3586_/D VGND VGND VPWR VPWR _3599_/A sky130_fd_sc_hd__o31a_2
XFILLER_114_242 VGND VGND VPWR VPWR sky130_fd_sc_hd__decap_3
XFILLER_114_253 VGND VGND VPWR VPWR sky130_fd_sc_hd__decap_3
XFILLER_88_605 VGND VGND VPWR VPWR sky130_fd_sc_hd__decap_3
XFILLER_102_415 VGND VGND VPWR VPWR sky130_fd_sc_hd__decap_3
XFILLER_114_286 VGND VGND VPWR VPWR sky130_fd_sc_hd__decap_3
XFILLER_87_104 VGND VGND VPWR VPWR sky130_fd_sc_hd__decap_3
XFILLER_88_638 VGND VGND VPWR VPWR sky130_fd_sc_hd__decap_3
XFILLER_102_448 VGND VGND VPWR VPWR sky130_fd_sc_hd__decap_3
XFILLER_87_137 VGND VGND VPWR VPWR sky130_fd_sc_hd__decap_3
X_4206_ _4920_/A _4204_/Y _4205_/X VGND VGND VPWR VPWR _4206_/X sky130_fd_sc_hd__a21o_2
XFILLER_3_90 VGND VGND VPWR VPWR sky130_fd_sc_hd__decap_3
XFILLER_96_660 VGND VGND VPWR VPWR sky130_fd_sc_hd__decap_3
X_5186_ _5186_/A _5205_/B VGND VGND VPWR VPWR _7235_/D sky130_fd_sc_hd__and2_2
XFILLER_113_36 VGND VGND VPWR VPWR sky130_fd_sc_hd__decap_3
XFILLER_28_237 VGND VGND VPWR VPWR sky130_fd_sc_hd__decap_3
XFILLER_68_384 VGND VGND VPWR VPWR sky130_fd_sc_hd__decap_3
XFILLER_95_181 VGND VGND VPWR VPWR sky130_fd_sc_hd__decap_3
X_4137_ _7048_/Q _4501_/S _4419_/B1 _7395_/Q _4136_/X VGND VGND VPWR VPWR _4137_/X
+ sky130_fd_sc_hd__a221o_2
XTAP_TAPCELL_ROW_39_722 VGND VPWR sky130_fd_sc_hd__tapvpwrvgnd_1
XFILLER_113_69 VGND VGND VPWR VPWR sky130_fd_sc_hd__decap_3
XFILLER_28_259 VGND VGND VPWR VPWR sky130_fd_sc_hd__decap_3
XFILLER_43_207 VGND VGND VPWR VPWR sky130_fd_sc_hd__decap_3
XFILLER_71_505 VGND VGND VPWR VPWR sky130_fd_sc_hd__decap_3
XFILLER_71_516 VGND VGND VPWR VPWR sky130_fd_sc_hd__decap_3
X_4068_ _4068_/A _4082_/A VGND VGND VPWR VPWR _4069_/B sky130_fd_sc_hd__nor2_2
XFILLER_24_421 VGND VGND VPWR VPWR sky130_fd_sc_hd__decap_3
XFILLER_36_270 VGND VGND VPWR VPWR sky130_fd_sc_hd__decap_3
XFILLER_43_218 VGND VGND VPWR VPWR sky130_fd_sc_hd__decap_3
XFILLER_71_538 VGND VGND VPWR VPWR sky130_fd_sc_hd__decap_3
XTAP_TAPCELL_ROW_104_1503 VGND VPWR sky130_fd_sc_hd__tapvpwrvgnd_1
XFILLER_51_273 VGND VGND VPWR VPWR sky130_fd_sc_hd__decap_3
XFILLER_7_108 VGND VGND VPWR VPWR sky130_fd_sc_hd__decap_3
XFILLER_7_119 VGND VGND VPWR VPWR sky130_fd_sc_hd__decap_3
X_6709_ _7406_/CLK _6709_/D VGND VGND VPWR VPWR _6709_/Q sky130_fd_sc_hd__dfxtp_2
XFILLER_98_26 VGND VGND VPWR VPWR sky130_fd_sc_hd__fill_2
XFILLER_98_15 VGND VGND VPWR VPWR sky130_fd_sc_hd__decap_3
XTAP_TAPCELL_ROW_115_1632 VGND VPWR sky130_fd_sc_hd__tapvpwrvgnd_1
XFILLER_98_59 VGND VGND VPWR VPWR sky130_fd_sc_hd__decap_3
XFILLER_3_369 VGND VGND VPWR VPWR sky130_fd_sc_hd__decap_3
XFILLER_79_605 VGND VGND VPWR VPWR sky130_fd_sc_hd__decap_3
XFILLER_105_264 VGND VGND VPWR VPWR sky130_fd_sc_hd__decap_3
XFILLER_78_104 VGND VGND VPWR VPWR sky130_fd_sc_hd__decap_3
XFILLER_79_638 VGND VGND VPWR VPWR sky130_fd_sc_hd__decap_3
XFILLER_78_159 VGND VGND VPWR VPWR sky130_fd_sc_hd__decap_3
Xoutput490 _3746_/C VGND VGND VPWR VPWR alu_result_out[5] sky130_fd_sc_hd__clkdlybuf4s25_1
XFILLER_47_30 VGND VGND VPWR VPWR sky130_fd_sc_hd__decap_3
XFILLER_87_671 VGND VGND VPWR VPWR sky130_fd_sc_hd__fill_1
XFILLER_87_682 VGND VGND VPWR VPWR sky130_fd_sc_hd__decap_3
XFILLER_47_52 VGND VGND VPWR VPWR sky130_fd_sc_hd__decap_3
XFILLER_47_546 VGND VGND VPWR VPWR sky130_fd_sc_hd__decap_3
XFILLER_19_248 VGND VGND VPWR VPWR sky130_fd_sc_hd__decap_3
XFILLER_74_365 VGND VGND VPWR VPWR sky130_fd_sc_hd__decap_3
XFILLER_34_218 VGND VGND VPWR VPWR sky130_fd_sc_hd__decap_3
XFILLER_27_281 VGND VGND VPWR VPWR sky130_fd_sc_hd__decap_3
XFILLER_42_240 VGND VGND VPWR VPWR sky130_fd_sc_hd__decap_3
XFILLER_42_262 VGND VGND VPWR VPWR sky130_fd_sc_hd__decap_3
XFILLER_63_73 VGND VGND VPWR VPWR sky130_fd_sc_hd__decap_3
XFILLER_70_571 VGND VGND VPWR VPWR sky130_fd_sc_hd__decap_3
XFILLER_97_9 VGND VGND VPWR VPWR sky130_fd_sc_hd__decap_3
XFILLER_42_284 VGND VGND VPWR VPWR sky130_fd_sc_hd__fill_1
XFILLER_8_35 VGND VGND VPWR VPWR sky130_fd_sc_hd__decap_3
XFILLER_11_682 VGND VGND VPWR VPWR sky130_fd_sc_hd__decap_3
XFILLER_8_68 VGND VGND VPWR VPWR sky130_fd_sc_hd__decap_3
XFILLER_6_130 VGND VGND VPWR VPWR sky130_fd_sc_hd__decap_3
XFILLER_6_141 VGND VGND VPWR VPWR sky130_fd_sc_hd__decap_3
Xhold609 _6885_/Q VGND VGND VPWR VPWR _6885_/D sky130_fd_sc_hd__dlygate4sd3_1
XFILLER_109_570 VGND VGND VPWR VPWR sky130_fd_sc_hd__decap_3
XFILLER_6_185 VGND VGND VPWR VPWR sky130_fd_sc_hd__fill_2
X_3370_ _3561_/A _6983_/Q VGND VGND VPWR VPWR _3370_/Y sky130_fd_sc_hd__nor2_2
XFILLER_88_81 VGND VGND VPWR VPWR sky130_fd_sc_hd__decap_3
XTAP_TAPCELL_ROW_90_1337 VGND VPWR sky130_fd_sc_hd__tapvpwrvgnd_1
XTAP_TAPCELL_ROW_90_1326 VGND VPWR sky130_fd_sc_hd__tapvpwrvgnd_1
XFILLER_111_223 VGND VGND VPWR VPWR sky130_fd_sc_hd__fill_1
XFILLER_2_380 VGND VGND VPWR VPWR sky130_fd_sc_hd__decap_3
XFILLER_85_608 VGND VGND VPWR VPWR sky130_fd_sc_hd__decap_3
X_5040_ _6989_/D _5039_/X _5156_/S VGND VGND VPWR VPWR _5040_/X sky130_fd_sc_hd__mux2_2
XFILLER_26_3 VGND VGND VPWR VPWR sky130_fd_sc_hd__decap_3
XFILLER_78_660 VGND VGND VPWR VPWR sky130_fd_sc_hd__decap_3
XFILLER_97_479 VGND VGND VPWR VPWR sky130_fd_sc_hd__decap_3
XPHY_EDGE_ROW_108_Left_225 VGND VGND VPWR VPWR sky130_fd_sc_hd__decap_3
XFILLER_84_129 VGND VGND VPWR VPWR sky130_fd_sc_hd__decap_3
XFILLER_93_641 VGND VGND VPWR VPWR sky130_fd_sc_hd__decap_3
XFILLER_38_557 VGND VGND VPWR VPWR sky130_fd_sc_hd__fill_1
XFILLER_53_505 VGND VGND VPWR VPWR sky130_fd_sc_hd__decap_3
XFILLER_65_343 VGND VGND VPWR VPWR sky130_fd_sc_hd__decap_3
X_6991_ _7337_/CLK _6991_/D _6271_/Y VGND VGND VPWR VPWR _6991_/Q sky130_fd_sc_hd__dfrtp_2
XFILLER_65_387 VGND VGND VPWR VPWR sky130_fd_sc_hd__decap_3
XFILLER_80_324 VGND VGND VPWR VPWR sky130_fd_sc_hd__decap_3
XFILLER_80_368 VGND VGND VPWR VPWR sky130_fd_sc_hd__decap_3
XFILLER_21_402 VGND VGND VPWR VPWR sky130_fd_sc_hd__decap_3
XFILLER_33_240 VGND VGND VPWR VPWR sky130_fd_sc_hd__decap_3
XFILLER_33_251 VGND VGND VPWR VPWR sky130_fd_sc_hd__decap_3
XFILLER_80_379 VGND VGND VPWR VPWR sky130_fd_sc_hd__fill_2
XFILLER_61_593 VGND VGND VPWR VPWR sky130_fd_sc_hd__decap_3
XTAP_TAPCELL_ROW_44_780 VGND VPWR sky130_fd_sc_hd__tapvpwrvgnd_1
X_4755_ _7005_/Q _4775_/A VGND VGND VPWR VPWR _7005_/D sky130_fd_sc_hd__xor2_2
XFILLER_107_529 VGND VGND VPWR VPWR sky130_fd_sc_hd__decap_3
X_4686_ _6999_/Q _7000_/Q _4858_/B VGND VGND VPWR VPWR _4687_/B sky130_fd_sc_hd__and3_2
X_6425_ _6584_/A VGND VGND VPWR VPWR _6425_/Y sky130_fd_sc_hd__inv_2
X_3637_ _3636_/Y _5146_/B1 _3505_/X _3618_/X VGND VGND VPWR VPWR _3637_/X sky130_fd_sc_hd__a22o_2
XFILLER_108_47 VGND VGND VPWR VPWR sky130_fd_sc_hd__decap_3
X_6356_ _6388_/A VGND VGND VPWR VPWR _6356_/Y sky130_fd_sc_hd__inv_2
X_3568_ _7093_/Q _3417_/X _3407_/X _7125_/Q VGND VGND VPWR VPWR _3568_/X sky130_fd_sc_hd__a22o_2
XFILLER_115_573 VGND VGND VPWR VPWR sky130_fd_sc_hd__decap_3
XFILLER_68_29 VGND VGND VPWR VPWR sky130_fd_sc_hd__fill_2
XFILLER_88_413 VGND VGND VPWR VPWR sky130_fd_sc_hd__decap_3
XFILLER_88_424 VGND VGND VPWR VPWR sky130_fd_sc_hd__decap_3
XFILLER_102_245 VGND VGND VPWR VPWR sky130_fd_sc_hd__decap_3
X_6287_ _6288_/A VGND VGND VPWR VPWR _6287_/Y sky130_fd_sc_hd__inv_2
X_3499_ _4537_/C _4289_/B _3497_/X _5152_/B VGND VGND VPWR VPWR _3541_/B sky130_fd_sc_hd__a31oi_4
XFILLER_102_256 VGND VGND VPWR VPWR sky130_fd_sc_hd__decap_3
XFILLER_69_671 VGND VGND VPWR VPWR sky130_fd_sc_hd__fill_1
XFILLER_75_107 VGND VGND VPWR VPWR sky130_fd_sc_hd__fill_2
X_5238_ _5362_/C _5238_/B _3378_/Y VGND VGND VPWR VPWR _5238_/X sky130_fd_sc_hd__or3b_2
XTAP_TAPCELL_ROW_110_1573 VGND VPWR sky130_fd_sc_hd__tapvpwrvgnd_1
XFILLER_102_289 VGND VGND VPWR VPWR sky130_fd_sc_hd__decap_3
XFILLER_68_170 VGND VGND VPWR VPWR sky130_fd_sc_hd__decap_3
XFILLER_69_682 VGND VGND VPWR VPWR sky130_fd_sc_hd__decap_3
XFILLER_96_490 VGND VGND VPWR VPWR sky130_fd_sc_hd__fill_2
X_5169_ _5169_/A _5182_/B VGND VGND VPWR VPWR _7243_/D sky130_fd_sc_hd__and2_2
XFILLER_44_505 VGND VGND VPWR VPWR sky130_fd_sc_hd__decap_3
XFILLER_83_140 VGND VGND VPWR VPWR sky130_fd_sc_hd__decap_3
XFILLER_84_663 VGND VGND VPWR VPWR sky130_fd_sc_hd__decap_3
XFILLER_16_218 VGND VGND VPWR VPWR sky130_fd_sc_hd__decap_3
XFILLER_16_229 VGND VGND VPWR VPWR sky130_fd_sc_hd__decap_3
XFILLER_17_33 VGND VGND VPWR VPWR sky130_fd_sc_hd__decap_3
XFILLER_17_55 VGND VGND VPWR VPWR sky130_fd_sc_hd__fill_1
XFILLER_71_313 VGND VGND VPWR VPWR sky130_fd_sc_hd__decap_3
XFILLER_83_162 VGND VGND VPWR VPWR sky130_fd_sc_hd__decap_3
XFILLER_17_66 VGND VGND VPWR VPWR sky130_fd_sc_hd__decap_3
XTAP_TAPCELL_ROW_65_1030 VGND VPWR sky130_fd_sc_hd__tapvpwrvgnd_1
XFILLER_24_251 VGND VGND VPWR VPWR sky130_fd_sc_hd__fill_1
XFILLER_24_262 VGND VGND VPWR VPWR sky130_fd_sc_hd__decap_3
XFILLER_71_368 VGND VGND VPWR VPWR sky130_fd_sc_hd__decap_3
XTAP_TAPCELL_ROW_14_419 VGND VPWR sky130_fd_sc_hd__tapvpwrvgnd_1
XFILLER_24_295 VGND VGND VPWR VPWR sky130_fd_sc_hd__decap_3
XFILLER_8_439 VGND VGND VPWR VPWR sky130_fd_sc_hd__decap_3
XFILLER_3_111 VGND VGND VPWR VPWR sky130_fd_sc_hd__fill_1
XFILLER_4_623 VGND VGND VPWR VPWR sky130_fd_sc_hd__decap_3
XFILLER_3_122 VGND VGND VPWR VPWR sky130_fd_sc_hd__decap_3
XFILLER_4_645 VGND VGND VPWR VPWR sky130_fd_sc_hd__decap_3
XFILLER_3_155 VGND VGND VPWR VPWR sky130_fd_sc_hd__decap_3
XFILLER_4_678 VGND VGND VPWR VPWR sky130_fd_sc_hd__decap_3
XFILLER_79_402 VGND VGND VPWR VPWR sky130_fd_sc_hd__decap_3
XFILLER_12_9 VGND VGND VPWR VPWR sky130_fd_sc_hd__decap_3
XFILLER_59_181 VGND VGND VPWR VPWR sky130_fd_sc_hd__decap_3
XFILLER_66_129 VGND VGND VPWR VPWR sky130_fd_sc_hd__decap_3
XFILLER_75_630 VGND VGND VPWR VPWR sky130_fd_sc_hd__decap_3
XFILLER_35_505 VGND VGND VPWR VPWR sky130_fd_sc_hd__fill_2
XFILLER_47_332 VGND VGND VPWR VPWR sky130_fd_sc_hd__decap_3
XFILLER_75_663 VGND VGND VPWR VPWR sky130_fd_sc_hd__decap_3
XFILLER_75_685 VGND VGND VPWR VPWR sky130_fd_sc_hd__decap_3
XFILLER_90_622 VGND VGND VPWR VPWR sky130_fd_sc_hd__decap_3
XFILLER_90_666 VGND VGND VPWR VPWR sky130_fd_sc_hd__decap_3
XFILLER_15_251 VGND VGND VPWR VPWR sky130_fd_sc_hd__decap_3
XFILLER_62_368 VGND VGND VPWR VPWR sky130_fd_sc_hd__decap_3
XFILLER_15_284 VGND VGND VPWR VPWR sky130_fd_sc_hd__decap_3
XFILLER_95_6 VGND VGND VPWR VPWR sky130_fd_sc_hd__decap_3
XFILLER_90_82 VGND VGND VPWR VPWR sky130_fd_sc_hd__fill_2
XFILLER_30_265 VGND VGND VPWR VPWR sky130_fd_sc_hd__decap_3
XFILLER_30_298 VGND VGND VPWR VPWR sky130_fd_sc_hd__decap_3
XFILLER_116_304 VGND VGND VPWR VPWR sky130_fd_sc_hd__decap_3
Xclkbuf_leaf_10_clk clkbuf_leaf_4_clk/A VGND VGND VPWR VPWR _7364_/CLK sky130_fd_sc_hd__clkbuf_16
X_4540_ _4540_/A _4571_/B VGND VGND VPWR VPWR _7310_/D sky130_fd_sc_hd__and2_2
XFILLER_116_337 VGND VGND VPWR VPWR sky130_fd_sc_hd__decap_3
XFILLER_7_461 VGND VGND VPWR VPWR sky130_fd_sc_hd__fill_2
X_4471_ _4471_/A0 _4470_/X _4471_/S VGND VGND VPWR VPWR _7343_/D sky130_fd_sc_hd__mux2_2
XFILLER_116_359 VGND VGND VPWR VPWR sky130_fd_sc_hd__decap_3
X_7190_ clkload9/A _7190_/D _6470_/Y VGND VGND VPWR VPWR _7190_/Q sky130_fd_sc_hd__dfrtp_2
XFILLER_112_521 VGND VGND VPWR VPWR sky130_fd_sc_hd__fill_2
X_3353_ _3353_/A _6979_/Q VGND VGND VPWR VPWR _5668_/A sky130_fd_sc_hd__xor2_2
XFILLER_112_554 VGND VGND VPWR VPWR sky130_fd_sc_hd__decap_3
XFILLER_112_587 VGND VGND VPWR VPWR sky130_fd_sc_hd__fill_1
XFILLER_58_619 VGND VGND VPWR VPWR sky130_fd_sc_hd__decap_3
XFILLER_85_416 VGND VGND VPWR VPWR sky130_fd_sc_hd__decap_3
Xhold1106 _7333_/Q VGND VGND VPWR VPWR _4493_/A0 sky130_fd_sc_hd__dlygate4sd3_1
XFILLER_112_598 VGND VGND VPWR VPWR sky130_fd_sc_hd__decap_3
XFILLER_78_490 VGND VGND VPWR VPWR sky130_fd_sc_hd__decap_3
XFILLER_85_449 VGND VGND VPWR VPWR sky130_fd_sc_hd__decap_3
XFILLER_97_287 VGND VGND VPWR VPWR sky130_fd_sc_hd__decap_3
Xhold1117 _7208_/Q VGND VGND VPWR VPWR _5243_/A0 sky130_fd_sc_hd__dlygate4sd3_1
Xhold1128 _7135_/Q VGND VGND VPWR VPWR _5396_/A0 sky130_fd_sc_hd__dlygate4sd3_1
Xhold1139 _7295_/Q VGND VGND VPWR VPWR _4571_/A sky130_fd_sc_hd__dlygate4sd3_1
X_5023_ _5661_/A VGND VGND VPWR VPWR _5023_/Y sky130_fd_sc_hd__inv_2
XFILLER_38_354 VGND VGND VPWR VPWR sky130_fd_sc_hd__decap_3
XFILLER_66_663 VGND VGND VPWR VPWR sky130_fd_sc_hd__decap_3
Xsingle_cycle_cpu_580 VGND VGND VPWR VPWR single_cycle_cpu_580/HI instruction_out[31]
+ sky130_fd_sc_hd__conb_1
XFILLER_38_365 VGND VGND VPWR VPWR sky130_fd_sc_hd__decap_3
XFILLER_38_376 VGND VGND VPWR VPWR sky130_fd_sc_hd__decap_3
XFILLER_53_313 VGND VGND VPWR VPWR sky130_fd_sc_hd__decap_3
XFILLER_65_162 VGND VGND VPWR VPWR sky130_fd_sc_hd__decap_3
XFILLER_93_471 VGND VGND VPWR VPWR sky130_fd_sc_hd__decap_3
XFILLER_0_80 VGND VGND VPWR VPWR sky130_fd_sc_hd__decap_3
XFILLER_19_590 VGND VGND VPWR VPWR sky130_fd_sc_hd__decap_3
XFILLER_65_184 VGND VGND VPWR VPWR sky130_fd_sc_hd__decap_3
XFILLER_80_132 VGND VGND VPWR VPWR sky130_fd_sc_hd__decap_3
XFILLER_81_644 VGND VGND VPWR VPWR sky130_fd_sc_hd__decap_3
X_6974_ _6976_/CLK _6974_/D VGND VGND VPWR VPWR _6974_/Q sky130_fd_sc_hd__dfxtp_2
XFILLER_110_15 VGND VGND VPWR VPWR sky130_fd_sc_hd__decap_3
XFILLER_81_688 VGND VGND VPWR VPWR sky130_fd_sc_hd__decap_3
XFILLER_110_59 VGND VGND VPWR VPWR sky130_fd_sc_hd__decap_3
XFILLER_61_390 VGND VGND VPWR VPWR sky130_fd_sc_hd__fill_2
XFILLER_21_243 VGND VGND VPWR VPWR sky130_fd_sc_hd__decap_3
X_4807_ _4807_/A0 _4806_/X _4901_/S VGND VGND VPWR VPWR _7273_/D sky130_fd_sc_hd__mux2_2
XPHY_EDGE_ROW_3_Right_3 VGND VGND VPWR VPWR sky130_fd_sc_hd__decap_3
X_4738_ _4738_/A _4738_/B VGND VGND VPWR VPWR _7006_/D sky130_fd_sc_hd__nor2_2
XFILLER_107_337 VGND VGND VPWR VPWR sky130_fd_sc_hd__decap_3
XFILLER_79_17 VGND VGND VPWR VPWR sky130_fd_sc_hd__decap_3
X_4669_ _6995_/Q _5622_/B VGND VGND VPWR VPWR _4928_/B sky130_fd_sc_hd__and2_2
XFILLER_107_348 VGND VGND VPWR VPWR sky130_fd_sc_hd__decap_3
Xhold940 _6695_/Q VGND VGND VPWR VPWR hold940/X sky130_fd_sc_hd__dlygate4sd3_1
X_6408_ _6570_/A VGND VGND VPWR VPWR _6408_/Y sky130_fd_sc_hd__inv_2
XFILLER_115_370 VGND VGND VPWR VPWR sky130_fd_sc_hd__decap_3
XFILLER_1_615 VGND VGND VPWR VPWR sky130_fd_sc_hd__fill_1
X_7388_ _7392_/CLK _7388_/D _6668_/Y VGND VGND VPWR VPWR _7388_/Q sky130_fd_sc_hd__dfrtp_2
Xhold973 _5737_/X VGND VGND VPWR VPWR _6718_/D sky130_fd_sc_hd__dlygate4sd3_1
Xhold962 _7379_/Q VGND VGND VPWR VPWR hold962/X sky130_fd_sc_hd__dlygate4sd3_1
Xhold951 _7049_/Q VGND VGND VPWR VPWR hold951/X sky130_fd_sc_hd__dlygate4sd3_1
XFILLER_103_543 VGND VGND VPWR VPWR sky130_fd_sc_hd__decap_3
XFILLER_1_637 VGND VGND VPWR VPWR sky130_fd_sc_hd__decap_3
Xhold995 _7402_/Q VGND VGND VPWR VPWR hold995/X sky130_fd_sc_hd__dlygate4sd3_1
Xhold984 _7042_/Q VGND VGND VPWR VPWR hold984/X sky130_fd_sc_hd__dlygate4sd3_1
X_6339_ _6347_/A VGND VGND VPWR VPWR _6339_/Y sky130_fd_sc_hd__inv_2
XFILLER_0_147 VGND VGND VPWR VPWR sky130_fd_sc_hd__decap_3
XFILLER_0_158 VGND VGND VPWR VPWR sky130_fd_sc_hd__decap_3
XFILLER_0_169 VGND VGND VPWR VPWR sky130_fd_sc_hd__fill_2
XFILLER_76_405 VGND VGND VPWR VPWR sky130_fd_sc_hd__decap_3
XFILLER_28_21 VGND VGND VPWR VPWR sky130_fd_sc_hd__decap_3
XFILLER_76_427 VGND VGND VPWR VPWR sky130_fd_sc_hd__decap_3
XFILLER_57_641 VGND VGND VPWR VPWR sky130_fd_sc_hd__decap_3
XFILLER_17_516 VGND VGND VPWR VPWR sky130_fd_sc_hd__decap_3
XFILLER_28_76 VGND VGND VPWR VPWR sky130_fd_sc_hd__decap_3
XFILLER_28_98 VGND VGND VPWR VPWR sky130_fd_sc_hd__decap_3
XFILLER_56_162 VGND VGND VPWR VPWR sky130_fd_sc_hd__decap_3
XFILLER_57_685 VGND VGND VPWR VPWR sky130_fd_sc_hd__decap_3
XFILLER_84_460 VGND VGND VPWR VPWR sky130_fd_sc_hd__decap_3
XFILLER_71_132 VGND VGND VPWR VPWR sky130_fd_sc_hd__decap_3
XFILLER_72_633 VGND VGND VPWR VPWR sky130_fd_sc_hd__decap_3
XFILLER_72_666 VGND VGND VPWR VPWR sky130_fd_sc_hd__decap_3
XFILLER_44_368 VGND VGND VPWR VPWR sky130_fd_sc_hd__decap_3
XFILLER_71_165 VGND VGND VPWR VPWR sky130_fd_sc_hd__decap_3
XTAP_TAPCELL_ROW_27_577 VGND VPWR sky130_fd_sc_hd__tapvpwrvgnd_1
XFILLER_12_221 VGND VGND VPWR VPWR sky130_fd_sc_hd__decap_3
XFILLER_40_530 VGND VGND VPWR VPWR sky130_fd_sc_hd__fill_2
XFILLER_44_64 VGND VGND VPWR VPWR sky130_fd_sc_hd__decap_3
XFILLER_71_187 VGND VGND VPWR VPWR sky130_fd_sc_hd__decap_3
XFILLER_100_81 VGND VGND VPWR VPWR sky130_fd_sc_hd__decap_3
XFILLER_12_265 VGND VGND VPWR VPWR sky130_fd_sc_hd__decap_3
XFILLER_12_298 VGND VGND VPWR VPWR sky130_fd_sc_hd__decap_3
XFILLER_60_96 VGND VGND VPWR VPWR sky130_fd_sc_hd__decap_3
XFILLER_4_442 VGND VGND VPWR VPWR sky130_fd_sc_hd__decap_3
XFILLER_5_36 VGND VGND VPWR VPWR sky130_fd_sc_hd__decap_3
XFILLER_99_508 VGND VGND VPWR VPWR sky130_fd_sc_hd__decap_3
XFILLER_109_90 VGND VGND VPWR VPWR sky130_fd_sc_hd__decap_3
XFILLER_5_69 VGND VGND VPWR VPWR sky130_fd_sc_hd__decap_3
XFILLER_106_392 VGND VGND VPWR VPWR sky130_fd_sc_hd__decap_3
XFILLER_69_72 VGND VGND VPWR VPWR sky130_fd_sc_hd__decap_3
XFILLER_79_243 VGND VGND VPWR VPWR sky130_fd_sc_hd__decap_3
XFILLER_0_670 VGND VGND VPWR VPWR sky130_fd_sc_hd__fill_2
XFILLER_67_427 VGND VGND VPWR VPWR sky130_fd_sc_hd__decap_3
XFILLER_94_235 VGND VGND VPWR VPWR sky130_fd_sc_hd__decap_3
XFILLER_10_6 VGND VGND VPWR VPWR sky130_fd_sc_hd__decap_3
XFILLER_47_140 VGND VGND VPWR VPWR sky130_fd_sc_hd__decap_3
XFILLER_48_663 VGND VGND VPWR VPWR sky130_fd_sc_hd__decap_3
XFILLER_82_408 VGND VGND VPWR VPWR sky130_fd_sc_hd__decap_3
XFILLER_85_82 VGND VGND VPWR VPWR sky130_fd_sc_hd__fill_2
XFILLER_35_324 VGND VGND VPWR VPWR sky130_fd_sc_hd__fill_2
XFILLER_35_346 VGND VGND VPWR VPWR sky130_fd_sc_hd__decap_3
XFILLER_62_110 VGND VGND VPWR VPWR sky130_fd_sc_hd__decap_3
XFILLER_63_644 VGND VGND VPWR VPWR sky130_fd_sc_hd__decap_3
XFILLER_90_430 VGND VGND VPWR VPWR sky130_fd_sc_hd__fill_1
XFILLER_23_508 VGND VGND VPWR VPWR sky130_fd_sc_hd__decap_3
XTAP_TAPCELL_ROW_85_1269 VGND VPWR sky130_fd_sc_hd__tapvpwrvgnd_1
XFILLER_16_571 VGND VGND VPWR VPWR sky130_fd_sc_hd__fill_2
XFILLER_50_349 VGND VGND VPWR VPWR sky130_fd_sc_hd__fill_2
X_5710_ _7361_/Q hold921/X _5721_/S VGND VGND VPWR VPWR _6705_/D sky130_fd_sc_hd__mux2_2
XFILLER_31_541 VGND VGND VPWR VPWR sky130_fd_sc_hd__fill_2
XFILLER_93_3 VGND VGND VPWR VPWR sky130_fd_sc_hd__decap_3
X_6690_ clkload9/A _6690_/D VGND VGND VPWR VPWR _6690_/Q sky130_fd_sc_hd__dfxtp_2
X_5641_ _5641_/A VGND VGND VPWR VPWR _5641_/Y sky130_fd_sc_hd__inv_2
X_5572_ hold979/X _5598_/A2 _4961_/C VGND VGND VPWR VPWR _7045_/D sky130_fd_sc_hd__a21o_2
X_7311_ _7360_/CLK _7311_/D _6591_/Y VGND VGND VPWR VPWR _7311_/Q sky130_fd_sc_hd__dfrtp_2
X_7242_ _7368_/CLK _7242_/D _6522_/Y VGND VGND VPWR VPWR _7242_/Q sky130_fd_sc_hd__dfrtp_2
XFILLER_104_318 VGND VGND VPWR VPWR sky130_fd_sc_hd__decap_3
XFILLER_116_167 VGND VGND VPWR VPWR sky130_fd_sc_hd__fill_1
XFILLER_116_178 VGND VGND VPWR VPWR sky130_fd_sc_hd__decap_3
X_4454_ _4761_/B _4761_/C _4069_/Y _4762_/B VGND VGND VPWR VPWR _4454_/X sky130_fd_sc_hd__a211o_2
XTAP_TAPCELL_ROW_96_1398 VGND VPWR sky130_fd_sc_hd__tapvpwrvgnd_1
X_7173_ _7368_/CLK _7173_/D _6453_/Y VGND VGND VPWR VPWR _7173_/Q sky130_fd_sc_hd__dfrtp_2
X_4385_ _7337_/Q _3945_/S _5229_/C _7145_/Q VGND VGND VPWR VPWR _4385_/X sky130_fd_sc_hd__a22o_2
X_3405_ _6982_/Q _4697_/A _3340_/C _4667_/B VGND VGND VPWR VPWR _3409_/D sky130_fd_sc_hd__o31a_2
XFILLER_98_530 VGND VGND VPWR VPWR sky130_fd_sc_hd__fill_2
XFILLER_105_15 VGND VGND VPWR VPWR sky130_fd_sc_hd__decap_3
XFILLER_105_48 VGND VGND VPWR VPWR sky130_fd_sc_hd__decap_3
XFILLER_73_408 VGND VGND VPWR VPWR sky130_fd_sc_hd__decap_3
XFILLER_85_257 VGND VGND VPWR VPWR sky130_fd_sc_hd__fill_2
X_5006_ _5072_/A _4626_/X _5003_/A _5033_/B2 VGND VGND VPWR VPWR _5006_/X sky130_fd_sc_hd__a22o_2
XFILLER_26_302 VGND VGND VPWR VPWR sky130_fd_sc_hd__decap_3
XFILLER_39_685 VGND VGND VPWR VPWR sky130_fd_sc_hd__decap_3
XFILLER_54_622 VGND VGND VPWR VPWR sky130_fd_sc_hd__decap_3
XFILLER_73_419 VGND VGND VPWR VPWR sky130_fd_sc_hd__decap_3
XFILLER_66_493 VGND VGND VPWR VPWR sky130_fd_sc_hd__decap_3
XFILLER_14_519 VGND VGND VPWR VPWR sky130_fd_sc_hd__decap_3
XFILLER_26_368 VGND VGND VPWR VPWR sky130_fd_sc_hd__fill_1
XFILLER_54_666 VGND VGND VPWR VPWR sky130_fd_sc_hd__decap_3
XFILLER_81_18 VGND VGND VPWR VPWR sky130_fd_sc_hd__decap_3
XFILLER_81_452 VGND VGND VPWR VPWR sky130_fd_sc_hd__decap_3
XFILLER_81_474 VGND VGND VPWR VPWR sky130_fd_sc_hd__decap_3
X_6957_ _6978_/CLK _6957_/D VGND VGND VPWR VPWR _6957_/Q sky130_fd_sc_hd__dfxtp_2
XTAP_TAPCELL_ROW_62_1000 VGND VPWR sky130_fd_sc_hd__tapvpwrvgnd_1
XTAP_TAPCELL_ROW_24_536 VGND VPWR sky130_fd_sc_hd__tapvpwrvgnd_1
XFILLER_14_12 VGND VGND VPWR VPWR sky130_fd_sc_hd__decap_3
XFILLER_22_530 VGND VGND VPWR VPWR sky130_fd_sc_hd__fill_2
X_6888_ _6965_/CLK _6888_/D VGND VGND VPWR VPWR _6888_/Q sky130_fd_sc_hd__dfxtp_2
XTAP_TAPCELL_ROW_52_878 VGND VPWR sky130_fd_sc_hd__tapvpwrvgnd_1
XFILLER_14_56 VGND VGND VPWR VPWR sky130_fd_sc_hd__decap_3
XFILLER_108_613 VGND VGND VPWR VPWR sky130_fd_sc_hd__decap_3
XFILLER_30_11 VGND VGND VPWR VPWR sky130_fd_sc_hd__decap_3
XFILLER_108_657 VGND VGND VPWR VPWR sky130_fd_sc_hd__decap_3
XFILLER_30_44 VGND VGND VPWR VPWR sky130_fd_sc_hd__decap_3
XFILLER_107_167 VGND VGND VPWR VPWR sky130_fd_sc_hd__fill_1
XFILLER_30_77 VGND VGND VPWR VPWR sky130_fd_sc_hd__decap_3
XFILLER_1_423 VGND VGND VPWR VPWR sky130_fd_sc_hd__decap_3
XFILLER_89_530 VGND VGND VPWR VPWR sky130_fd_sc_hd__decap_3
Xhold770 _6970_/Q VGND VGND VPWR VPWR _6970_/D sky130_fd_sc_hd__dlygate4sd3_1
Xhold781 _6769_/Q VGND VGND VPWR VPWR _6769_/D sky130_fd_sc_hd__dlygate4sd3_1
XFILLER_1_467 VGND VGND VPWR VPWR sky130_fd_sc_hd__fill_2
Xhold792 _6754_/Q VGND VGND VPWR VPWR _6754_/D sky130_fd_sc_hd__dlygate4sd3_1
XFILLER_103_373 VGND VGND VPWR VPWR sky130_fd_sc_hd__decap_3
XFILLER_49_416 VGND VGND VPWR VPWR sky130_fd_sc_hd__decap_3
XFILLER_49_449 VGND VGND VPWR VPWR sky130_fd_sc_hd__decap_3
XFILLER_39_97 VGND VGND VPWR VPWR sky130_fd_sc_hd__decap_3
XFILLER_29_151 VGND VGND VPWR VPWR sky130_fd_sc_hd__decap_3
XFILLER_29_162 VGND VGND VPWR VPWR sky130_fd_sc_hd__decap_3
XFILLER_64_419 VGND VGND VPWR VPWR sky130_fd_sc_hd__fill_1
XFILLER_76_279 VGND VGND VPWR VPWR sky130_fd_sc_hd__decap_3
XTAP_TAPCELL_ROW_4_294 VGND VPWR sky130_fd_sc_hd__tapvpwrvgnd_1
XFILLER_44_121 VGND VGND VPWR VPWR sky130_fd_sc_hd__decap_3
XFILLER_45_644 VGND VGND VPWR VPWR sky130_fd_sc_hd__decap_3
XFILLER_72_430 VGND VGND VPWR VPWR sky130_fd_sc_hd__decap_3
XFILLER_45_688 VGND VGND VPWR VPWR sky130_fd_sc_hd__decap_3
XFILLER_55_63 VGND VGND VPWR VPWR sky130_fd_sc_hd__decap_3
XFILLER_55_96 VGND VGND VPWR VPWR sky130_fd_sc_hd__decap_3
XFILLER_72_474 VGND VGND VPWR VPWR sky130_fd_sc_hd__fill_2
XFILLER_60_625 VGND VGND VPWR VPWR sky130_fd_sc_hd__decap_3
XFILLER_32_349 VGND VGND VPWR VPWR sky130_fd_sc_hd__decap_3
XFILLER_60_669 VGND VGND VPWR VPWR sky130_fd_sc_hd__decap_3
XFILLER_114_616 VGND VGND VPWR VPWR sky130_fd_sc_hd__decap_3
XFILLER_58_6 VGND VGND VPWR VPWR sky130_fd_sc_hd__fill_2
XFILLER_113_137 VGND VGND VPWR VPWR sky130_fd_sc_hd__decap_3
XFILLER_95_500 VGND VGND VPWR VPWR sky130_fd_sc_hd__decap_3
X_4170_ _4203_/A _4203_/B _4202_/A VGND VGND VPWR VPWR _4938_/B sky130_fd_sc_hd__and3_2
XFILLER_96_81 VGND VGND VPWR VPWR sky130_fd_sc_hd__decap_3
XFILLER_75_290 VGND VGND VPWR VPWR sky130_fd_sc_hd__decap_3
XFILLER_51_614 VGND VGND VPWR VPWR sky130_fd_sc_hd__fill_2
XFILLER_63_441 VGND VGND VPWR VPWR sky130_fd_sc_hd__decap_3
Xplace430 _3371_/Y VGND VGND VPWR VPWR _4471_/S sky130_fd_sc_hd__buf_2
X_6811_ _6909_/CLK _6811_/D VGND VGND VPWR VPWR _6811_/Q sky130_fd_sc_hd__dfxtp_2
XFILLER_23_327 VGND VGND VPWR VPWR sky130_fd_sc_hd__decap_3
XFILLER_51_647 VGND VGND VPWR VPWR sky130_fd_sc_hd__decap_3
XFILLER_90_271 VGND VGND VPWR VPWR sky130_fd_sc_hd__decap_3
Xplace441 _5015_/A VGND VGND VPWR VPWR _5570_/A2 sky130_fd_sc_hd__buf_2
Xplace452 _6983_/Q VGND VGND VPWR VPWR _4697_/A sky130_fd_sc_hd__buf_2
XFILLER_50_135 VGND VGND VPWR VPWR sky130_fd_sc_hd__fill_2
X_6742_ _6972_/CLK _6742_/D VGND VGND VPWR VPWR _6742_/Q sky130_fd_sc_hd__dfxtp_2
X_3954_ _7363_/Q _4497_/A0 _3954_/S VGND VGND VPWR VPWR _7363_/D sky130_fd_sc_hd__mux2_2
XFILLER_31_371 VGND VGND VPWR VPWR sky130_fd_sc_hd__decap_3
X_6673_ _6674_/A VGND VGND VPWR VPWR _6673_/Y sky130_fd_sc_hd__inv_2
X_3885_ _3746_/X _3882_/X _3884_/X _3725_/X VGND VGND VPWR VPWR _3885_/X sky130_fd_sc_hd__a22o_2
XTAP_TAPCELL_ROW_21_506 VGND VPWR sky130_fd_sc_hd__tapvpwrvgnd_1
XFILLER_31_393 VGND VGND VPWR VPWR sky130_fd_sc_hd__decap_3
X_5624_ _5624_/A _5633_/B VGND VGND VPWR VPWR _7016_/D sky130_fd_sc_hd__or2_2
XTAP_TAPCELL_ROW_98_1427 VGND VPWR sky130_fd_sc_hd__tapvpwrvgnd_1
XFILLER_2_209 VGND VGND VPWR VPWR sky130_fd_sc_hd__fill_2
XFILLER_104_115 VGND VGND VPWR VPWR sky130_fd_sc_hd__fill_2
XFILLER_104_137 VGND VGND VPWR VPWR sky130_fd_sc_hd__decap_3
XFILLER_105_638 VGND VGND VPWR VPWR sky130_fd_sc_hd__decap_3
X_7225_ _7360_/CLK _7225_/D _6505_/Y VGND VGND VPWR VPWR _7225_/Q sky130_fd_sc_hd__dfrtp_2
X_4437_ _7022_/Q _4437_/A2 _4437_/B1 _7399_/Q _4436_/X VGND VGND VPWR VPWR _4437_/X
+ sky130_fd_sc_hd__a221o_2
XFILLER_116_47 VGND VGND VPWR VPWR sky130_fd_sc_hd__decap_3
X_7156_ clkload4/A _7156_/D _6436_/Y VGND VGND VPWR VPWR _7156_/Q sky130_fd_sc_hd__dfrtp_2
XFILLER_113_671 VGND VGND VPWR VPWR sky130_fd_sc_hd__fill_1
XFILLER_113_682 VGND VGND VPWR VPWR sky130_fd_sc_hd__fill_2
XFILLER_58_224 VGND VGND VPWR VPWR sky130_fd_sc_hd__decap_3
XFILLER_76_29 VGND VGND VPWR VPWR sky130_fd_sc_hd__decap_3
XFILLER_86_533 VGND VGND VPWR VPWR sky130_fd_sc_hd__decap_3
X_4368_ _5073_/A _4366_/X _5054_/A VGND VGND VPWR VPWR _4369_/B sky130_fd_sc_hd__a21oi_2
XFILLER_98_382 VGND VGND VPWR VPWR sky130_fd_sc_hd__decap_3
XFILLER_98_371 VGND VGND VPWR VPWR sky130_fd_sc_hd__fill_2
XFILLER_100_332 VGND VGND VPWR VPWR sky130_fd_sc_hd__fill_1
XFILLER_112_192 VGND VGND VPWR VPWR sky130_fd_sc_hd__decap_3
X_7087_ clkload4/A _7087_/D _6367_/Y VGND VGND VPWR VPWR _7087_/Q sky130_fd_sc_hd__dfstp_2
X_4299_ _3620_/A _4292_/X _4298_/X VGND VGND VPWR VPWR _5100_/B sky130_fd_sc_hd__a21o_2
X_3319_ _3378_/A _5646_/A _5647_/A _5647_/B VGND VGND VPWR VPWR _3319_/X sky130_fd_sc_hd__and4b_4
XFILLER_100_365 VGND VGND VPWR VPWR sky130_fd_sc_hd__decap_3
XFILLER_27_600 VGND VGND VPWR VPWR sky130_fd_sc_hd__fill_1
XFILLER_27_611 VGND VGND VPWR VPWR sky130_fd_sc_hd__decap_3
XFILLER_73_216 VGND VGND VPWR VPWR sky130_fd_sc_hd__decap_3
XTAP_TAPCELL_ROW_57_937 VGND VPWR sky130_fd_sc_hd__tapvpwrvgnd_1
XFILLER_100_398 VGND VGND VPWR VPWR sky130_fd_sc_hd__decap_3
XFILLER_27_633 VGND VGND VPWR VPWR sky130_fd_sc_hd__decap_3
XFILLER_39_482 VGND VGND VPWR VPWR sky130_fd_sc_hd__fill_2
XTAP_TAPCELL_ROW_107_1534 VGND VPWR sky130_fd_sc_hd__tapvpwrvgnd_1
XFILLER_27_655 VGND VGND VPWR VPWR sky130_fd_sc_hd__decap_3
XTAP_TAPCELL_ROW_1_264 VGND VPWR sky130_fd_sc_hd__tapvpwrvgnd_1
XFILLER_14_327 VGND VGND VPWR VPWR sky130_fd_sc_hd__decap_3
XFILLER_26_176 VGND VGND VPWR VPWR sky130_fd_sc_hd__decap_3
XFILLER_41_102 VGND VGND VPWR VPWR sky130_fd_sc_hd__fill_1
XFILLER_41_113 VGND VGND VPWR VPWR sky130_fd_sc_hd__decap_3
XTAP_TAPCELL_ROW_37_694 VGND VPWR sky130_fd_sc_hd__tapvpwrvgnd_1
XFILLER_10_500 VGND VGND VPWR VPWR sky130_fd_sc_hd__decap_3
XFILLER_10_511 VGND VGND VPWR VPWR sky130_fd_sc_hd__decap_3
XFILLER_25_99 VGND VGND VPWR VPWR sky130_fd_sc_hd__decap_3
XFILLER_10_522 VGND VGND VPWR VPWR sky130_fd_sc_hd__fill_2
XFILLER_10_533 VGND VGND VPWR VPWR sky130_fd_sc_hd__fill_1
XFILLER_41_32 VGND VGND VPWR VPWR sky130_fd_sc_hd__decap_3
XFILLER_108_410 VGND VGND VPWR VPWR sky130_fd_sc_hd__decap_3
XFILLER_6_504 VGND VGND VPWR VPWR sky130_fd_sc_hd__decap_3
XFILLER_41_87 VGND VGND VPWR VPWR sky130_fd_sc_hd__decap_3
XFILLER_104_660 VGND VGND VPWR VPWR sky130_fd_sc_hd__decap_3
XTAP_TAPCELL_ROW_9_364 VGND VPWR sky130_fd_sc_hd__tapvpwrvgnd_1
XFILLER_110_118 VGND VGND VPWR VPWR sky130_fd_sc_hd__decap_3
XFILLER_2_26 VGND VGND VPWR VPWR sky130_fd_sc_hd__fill_2
XFILLER_77_511 VGND VGND VPWR VPWR sky130_fd_sc_hd__decap_3
XFILLER_103_192 VGND VGND VPWR VPWR sky130_fd_sc_hd__decap_3
XFILLER_106_80 VGND VGND VPWR VPWR sky130_fd_sc_hd__decap_3
XFILLER_2_59 VGND VGND VPWR VPWR sky130_fd_sc_hd__decap_3
XFILLER_89_393 VGND VGND VPWR VPWR sky130_fd_sc_hd__decap_3
XFILLER_37_419 VGND VGND VPWR VPWR sky130_fd_sc_hd__decap_3
XFILLER_66_51 VGND VGND VPWR VPWR sky130_fd_sc_hd__decap_3
XFILLER_92_525 VGND VGND VPWR VPWR sky130_fd_sc_hd__decap_3
XFILLER_17_110 VGND VGND VPWR VPWR sky130_fd_sc_hd__fill_2
XFILLER_18_622 VGND VGND VPWR VPWR sky130_fd_sc_hd__decap_3
XFILLER_57_290 VGND VGND VPWR VPWR sky130_fd_sc_hd__decap_3
XFILLER_66_95 VGND VGND VPWR VPWR sky130_fd_sc_hd__decap_3
XFILLER_92_536 VGND VGND VPWR VPWR sky130_fd_sc_hd__decap_3
XFILLER_17_154 VGND VGND VPWR VPWR sky130_fd_sc_hd__decap_3
XFILLER_45_441 VGND VGND VPWR VPWR sky130_fd_sc_hd__decap_3
XFILLER_32_113 VGND VGND VPWR VPWR sky130_fd_sc_hd__decap_3
XFILLER_82_50 VGND VGND VPWR VPWR sky130_fd_sc_hd__decap_3
XFILLER_82_83 VGND VGND VPWR VPWR sky130_fd_sc_hd__fill_1
XTAP_TAPCELL_ROW_82_1239 VGND VPWR sky130_fd_sc_hd__tapvpwrvgnd_1
XFILLER_60_466 VGND VGND VPWR VPWR sky130_fd_sc_hd__fill_2
XFILLER_60_477 VGND VGND VPWR VPWR sky130_fd_sc_hd__decap_3
XFILLER_41_691 VGND VGND VPWR VPWR sky130_fd_sc_hd__fill_1
XFILLER_40_190 VGND VGND VPWR VPWR sky130_fd_sc_hd__decap_3
X_3670_ _3629_/A _3669_/X _3442_/A VGND VGND VPWR VPWR _3670_/X sky130_fd_sc_hd__a21o_2
XFILLER_56_3 VGND VGND VPWR VPWR sky130_fd_sc_hd__decap_3
X_5340_ _5340_/A0 _5079_/X _5360_/S VGND VGND VPWR VPWR _7161_/D sky130_fd_sc_hd__mux2_2
XFILLER_99_102 VGND VGND VPWR VPWR sky130_fd_sc_hd__decap_3
XFILLER_114_424 VGND VGND VPWR VPWR sky130_fd_sc_hd__fill_1
XFILLER_5_570 VGND VGND VPWR VPWR sky130_fd_sc_hd__decap_3
XTAP_TAPCELL_ROW_93_1368 VGND VPWR sky130_fd_sc_hd__tapvpwrvgnd_1
XFILLER_99_113 VGND VGND VPWR VPWR sky130_fd_sc_hd__decap_3
X_7010_ _7234_/CLK _7010_/D _6290_/Y VGND VGND VPWR VPWR _7010_/Q sky130_fd_sc_hd__dfrtp_2
X_4222_ _7356_/Q _4272_/B _4221_/X VGND VGND VPWR VPWR _4222_/X sky130_fd_sc_hd__a21o_2
XFILLER_101_107 VGND VGND VPWR VPWR sky130_fd_sc_hd__decap_3
XFILLER_101_129 VGND VGND VPWR VPWR sky130_fd_sc_hd__decap_3
XFILLER_68_522 VGND VGND VPWR VPWR sky130_fd_sc_hd__fill_1
X_4153_ _7298_/Q _4946_/S _4352_/B1 _7170_/Q _4152_/X VGND VGND VPWR VPWR _4153_/X
+ sky130_fd_sc_hd__a221o_2
XFILLER_110_663 VGND VGND VPWR VPWR sky130_fd_sc_hd__decap_3
X_4084_ _7302_/Q _4493_/S _4083_/X _4429_/C1 VGND VGND VPWR VPWR _4084_/X sky130_fd_sc_hd__a211o_2
XFILLER_83_536 VGND VGND VPWR VPWR sky130_fd_sc_hd__decap_3
XFILLER_83_558 VGND VGND VPWR VPWR sky130_fd_sc_hd__fill_2
XFILLER_95_396 VGND VGND VPWR VPWR sky130_fd_sc_hd__decap_3
XFILLER_102_27 VGND VGND VPWR VPWR sky130_fd_sc_hd__fill_1
XFILLER_36_463 VGND VGND VPWR VPWR sky130_fd_sc_hd__decap_3
XFILLER_83_569 VGND VGND VPWR VPWR sky130_fd_sc_hd__decap_3
XFILLER_102_49 VGND VGND VPWR VPWR sky130_fd_sc_hd__decap_3
XFILLER_23_102 VGND VGND VPWR VPWR sky130_fd_sc_hd__decap_3
XFILLER_23_113 VGND VGND VPWR VPWR sky130_fd_sc_hd__decap_3
XFILLER_36_485 VGND VGND VPWR VPWR sky130_fd_sc_hd__fill_1
XFILLER_51_411 VGND VGND VPWR VPWR sky130_fd_sc_hd__decap_3
XFILLER_51_444 VGND VGND VPWR VPWR sky130_fd_sc_hd__decap_3
XFILLER_63_293 VGND VGND VPWR VPWR sky130_fd_sc_hd__decap_3
Xplace282 _3887_/A2 VGND VGND VPWR VPWR _5660_/B sky130_fd_sc_hd__buf_2
Xplace271 _3892_/B1 VGND VGND VPWR VPWR _3888_/B1 sky130_fd_sc_hd__buf_2
X_4986_ _5003_/A _5003_/B _4626_/X VGND VGND VPWR VPWR _4987_/B sky130_fd_sc_hd__a21oi_2
Xplace293 _3913_/A2 VGND VGND VPWR VPWR _3862_/B1 sky130_fd_sc_hd__buf_2
X_6725_ _6975_/CLK _6725_/D VGND VGND VPWR VPWR _6725_/Q sky130_fd_sc_hd__dfxtp_2
X_3937_ _7371_/Q _4480_/A0 _3945_/S VGND VGND VPWR VPWR _7371_/D sky130_fd_sc_hd__mux2_2
XTAP_TAPCELL_ROW_62_995 VGND VPWR sky130_fd_sc_hd__tapvpwrvgnd_1
XTAP_TAPCELL_ROW_34_664 VGND VPWR sky130_fd_sc_hd__tapvpwrvgnd_1
XTAP_TAPCELL_ROW_102_1475 VGND VPWR sky130_fd_sc_hd__tapvpwrvgnd_1
XFILLER_109_218 VGND VGND VPWR VPWR sky130_fd_sc_hd__fill_1
XFILLER_31_190 VGND VGND VPWR VPWR sky130_fd_sc_hd__decap_3
X_6656_ _6670_/A VGND VGND VPWR VPWR _6656_/Y sky130_fd_sc_hd__inv_2
X_3868_ hold957/X _5104_/A _3867_/X VGND VGND VPWR VPWR _7384_/D sky130_fd_sc_hd__a21o_2
XFILLER_11_24 VGND VGND VPWR VPWR sky130_fd_sc_hd__decap_3
X_6587_ _6587_/A VGND VGND VPWR VPWR _6587_/Y sky130_fd_sc_hd__inv_2
X_5607_ _5607_/A _5634_/B VGND VGND VPWR VPWR _7024_/D sky130_fd_sc_hd__and2_2
X_3799_ _6909_/Q _3892_/A2 _3893_/B1 _6853_/Q VGND VGND VPWR VPWR _3799_/X sky130_fd_sc_hd__a22o_2
XFILLER_105_402 VGND VGND VPWR VPWR sky130_fd_sc_hd__decap_3
XFILLER_11_57 VGND VGND VPWR VPWR sky130_fd_sc_hd__decap_3
XFILLER_105_446 VGND VGND VPWR VPWR sky130_fd_sc_hd__fill_2
X_7208_ _7334_/CLK _7208_/D _6488_/Y VGND VGND VPWR VPWR _7208_/Q sky130_fd_sc_hd__dfrtp_2
XFILLER_59_500 VGND VGND VPWR VPWR sky130_fd_sc_hd__decap_3
XTAP_TAPCELL_ROW_6_323 VGND VPWR sky130_fd_sc_hd__tapvpwrvgnd_1
XFILLER_99_691 VGND VGND VPWR VPWR sky130_fd_sc_hd__fill_1
XFILLER_101_641 VGND VGND VPWR VPWR sky130_fd_sc_hd__decap_3
XFILLER_86_330 VGND VGND VPWR VPWR sky130_fd_sc_hd__fill_1
X_7139_ _7363_/CLK _7139_/D _6419_/Y VGND VGND VPWR VPWR _7139_/Q sky130_fd_sc_hd__dfrtp_2
XFILLER_101_685 VGND VGND VPWR VPWR sky130_fd_sc_hd__decap_3
XFILLER_59_599 VGND VGND VPWR VPWR sky130_fd_sc_hd__decap_3
XFILLER_86_352 VGND VGND VPWR VPWR sky130_fd_sc_hd__decap_3
XFILLER_86_374 VGND VGND VPWR VPWR sky130_fd_sc_hd__decap_3
XFILLER_36_21 VGND VGND VPWR VPWR sky130_fd_sc_hd__decap_3
XFILLER_46_227 VGND VGND VPWR VPWR sky130_fd_sc_hd__decap_3
XFILLER_39_290 VGND VGND VPWR VPWR sky130_fd_sc_hd__decap_3
XFILLER_61_208 VGND VGND VPWR VPWR sky130_fd_sc_hd__decap_3
XFILLER_15_625 VGND VGND VPWR VPWR sky130_fd_sc_hd__fill_1
XTAP_TAPCELL_ROW_68_1072 VGND VPWR sky130_fd_sc_hd__tapvpwrvgnd_1
XFILLER_36_98 VGND VGND VPWR VPWR sky130_fd_sc_hd__decap_3
XFILLER_54_293 VGND VGND VPWR VPWR sky130_fd_sc_hd__decap_3
XFILLER_14_168 VGND VGND VPWR VPWR sky130_fd_sc_hd__fill_1
XFILLER_42_466 VGND VGND VPWR VPWR sky130_fd_sc_hd__decap_3
XFILLER_42_477 VGND VGND VPWR VPWR sky130_fd_sc_hd__decap_3
XFILLER_52_20 VGND VGND VPWR VPWR sky130_fd_sc_hd__decap_3
XFILLER_10_330 VGND VGND VPWR VPWR sky130_fd_sc_hd__fill_1
XFILLER_10_363 VGND VGND VPWR VPWR sky130_fd_sc_hd__fill_1
XFILLER_6_323 VGND VGND VPWR VPWR sky130_fd_sc_hd__decap_3
XFILLER_108_251 VGND VGND VPWR VPWR sky130_fd_sc_hd__fill_1
XFILLER_6_345 VGND VGND VPWR VPWR sky130_fd_sc_hd__decap_3
XFILLER_108_295 VGND VGND VPWR VPWR sky130_fd_sc_hd__decap_3
XFILLER_42_9 VGND VGND VPWR VPWR sky130_fd_sc_hd__decap_3
XFILLER_97_617 VGND VGND VPWR VPWR sky130_fd_sc_hd__decap_3
XFILLER_96_127 VGND VGND VPWR VPWR sky130_fd_sc_hd__decap_3
XFILLER_2_595 VGND VGND VPWR VPWR sky130_fd_sc_hd__decap_3
XFILLER_65_503 VGND VGND VPWR VPWR sky130_fd_sc_hd__fill_1
XFILLER_65_536 VGND VGND VPWR VPWR sky130_fd_sc_hd__fill_1
XFILLER_92_344 VGND VGND VPWR VPWR sky130_fd_sc_hd__decap_3
XFILLER_93_60 VGND VGND VPWR VPWR sky130_fd_sc_hd__decap_3
XFILLER_18_463 VGND VGND VPWR VPWR sky130_fd_sc_hd__decap_3
XFILLER_92_377 VGND VGND VPWR VPWR sky130_fd_sc_hd__decap_3
XFILLER_45_293 VGND VGND VPWR VPWR sky130_fd_sc_hd__decap_3
XFILLER_60_230 VGND VGND VPWR VPWR sky130_fd_sc_hd__decap_3
X_4840_ _4903_/B _4903_/C _4903_/A VGND VGND VPWR VPWR _4888_/B sky130_fd_sc_hd__a21oi_2
XFILLER_20_105 VGND VGND VPWR VPWR sky130_fd_sc_hd__decap_3
XFILLER_21_617 VGND VGND VPWR VPWR sky130_fd_sc_hd__decap_3
XFILLER_21_628 VGND VGND VPWR VPWR sky130_fd_sc_hd__fill_1
XFILLER_33_477 VGND VGND VPWR VPWR sky130_fd_sc_hd__decap_3
XFILLER_60_274 VGND VGND VPWR VPWR sky130_fd_sc_hd__decap_3
XFILLER_14_680 VGND VGND VPWR VPWR sky130_fd_sc_hd__decap_3
X_6510_ _6608_/A VGND VGND VPWR VPWR _6510_/Y sky130_fd_sc_hd__inv_2
X_4771_ _4836_/S _7005_/D _4760_/Y _4770_/X VGND VGND VPWR VPWR _4771_/X sky130_fd_sc_hd__o211a_2
XTAP_TAPCELL_ROW_31_623 VGND VPWR sky130_fd_sc_hd__tapvpwrvgnd_1
XFILLER_13_190 VGND VGND VPWR VPWR sky130_fd_sc_hd__decap_3
X_6441_ _6604_/A VGND VGND VPWR VPWR _6441_/Y sky130_fd_sc_hd__inv_2
X_6372_ _6567_/A VGND VGND VPWR VPWR _6372_/Y sky130_fd_sc_hd__inv_2
XTAP_TAPCELL_ROW_11_380 VGND VPWR sky130_fd_sc_hd__tapvpwrvgnd_1
X_5323_ _5323_/A0 _4945_/X _7412_/A VGND VGND VPWR VPWR _7169_/D sky130_fd_sc_hd__mux2_2
X_3584_ _3424_/S _3583_/X _5648_/B VGND VGND VPWR VPWR _3586_/D sky130_fd_sc_hd__a21oi_2
XFILLER_114_221 VGND VGND VPWR VPWR sky130_fd_sc_hd__decap_3
XFILLER_88_617 VGND VGND VPWR VPWR sky130_fd_sc_hd__decap_3
XFILLER_102_427 VGND VGND VPWR VPWR sky130_fd_sc_hd__decap_3
XFILLER_114_265 VGND VGND VPWR VPWR sky130_fd_sc_hd__decap_3
XFILLER_87_116 VGND VGND VPWR VPWR sky130_fd_sc_hd__decap_3
XFILLER_114_298 VGND VGND VPWR VPWR sky130_fd_sc_hd__decap_3
XFILLER_87_149 VGND VGND VPWR VPWR sky130_fd_sc_hd__decap_3
X_4205_ _4205_/A _4205_/B _4205_/C VGND VGND VPWR VPWR _4205_/X sky130_fd_sc_hd__and3_2
XFILLER_110_460 VGND VGND VPWR VPWR sky130_fd_sc_hd__decap_3
XFILLER_68_352 VGND VGND VPWR VPWR sky130_fd_sc_hd__decap_3
XFILLER_68_374 VGND VGND VPWR VPWR sky130_fd_sc_hd__fill_1
XFILLER_96_672 VGND VGND VPWR VPWR sky130_fd_sc_hd__decap_3
X_4136_ _7235_/Q _3318_/B _4417_/A2 _7299_/Q _4135_/X VGND VGND VPWR VPWR _4136_/X
+ sky130_fd_sc_hd__a221o_2
XFILLER_110_493 VGND VGND VPWR VPWR sky130_fd_sc_hd__fill_1
XFILLER_113_15 VGND VGND VPWR VPWR sky130_fd_sc_hd__decap_3
XFILLER_68_396 VGND VGND VPWR VPWR sky130_fd_sc_hd__decap_3
XFILLER_83_311 VGND VGND VPWR VPWR sky130_fd_sc_hd__decap_3
XTAP_TAPCELL_ROW_39_723 VGND VPWR sky130_fd_sc_hd__tapvpwrvgnd_1
XFILLER_113_48 VGND VGND VPWR VPWR sky130_fd_sc_hd__decap_3
XFILLER_28_249 VGND VGND VPWR VPWR sky130_fd_sc_hd__decap_3
XFILLER_56_569 VGND VGND VPWR VPWR sky130_fd_sc_hd__fill_1
X_4067_ _4068_/A _4082_/A VGND VGND VPWR VPWR _4744_/B sky130_fd_sc_hd__and2_2
XFILLER_83_377 VGND VGND VPWR VPWR sky130_fd_sc_hd__decap_3
XTAP_TAPCELL_ROW_104_1504 VGND VPWR sky130_fd_sc_hd__tapvpwrvgnd_1
XTAP_TAPCELL_ROW_19_480 VGND VPWR sky130_fd_sc_hd__tapvpwrvgnd_1
XFILLER_11_105 VGND VGND VPWR VPWR sky130_fd_sc_hd__decap_3
XFILLER_24_466 VGND VGND VPWR VPWR sky130_fd_sc_hd__decap_3
XFILLER_11_116 VGND VGND VPWR VPWR sky130_fd_sc_hd__decap_3
X_4969_ _4968_/Y _4969_/B _4969_/C VGND VGND VPWR VPWR _4969_/X sky130_fd_sc_hd__and3b_2
XFILLER_22_12 VGND VGND VPWR VPWR sky130_fd_sc_hd__decap_3
X_6708_ _7405_/CLK _6708_/D VGND VGND VPWR VPWR _6708_/Q sky130_fd_sc_hd__dfxtp_2
XFILLER_22_45 VGND VGND VPWR VPWR sky130_fd_sc_hd__decap_3
XFILLER_22_67 VGND VGND VPWR VPWR sky130_fd_sc_hd__decap_3
X_6639_ _6640_/A VGND VGND VPWR VPWR _6639_/Y sky130_fd_sc_hd__inv_2
XTAP_TAPCELL_ROW_115_1633 VGND VPWR sky130_fd_sc_hd__tapvpwrvgnd_1
XFILLER_3_337 VGND VGND VPWR VPWR sky130_fd_sc_hd__fill_2
XFILLER_105_287 VGND VGND VPWR VPWR sky130_fd_sc_hd__fill_2
XFILLER_78_116 VGND VGND VPWR VPWR sky130_fd_sc_hd__decap_3
XFILLER_79_617 VGND VGND VPWR VPWR sky130_fd_sc_hd__decap_3
Xoutput480 _5663_/B VGND VGND VPWR VPWR alu_result_out[25] sky130_fd_sc_hd__clkdlybuf4s25_1
XFILLER_59_330 VGND VGND VPWR VPWR sky130_fd_sc_hd__decap_3
XFILLER_94_609 VGND VGND VPWR VPWR sky130_fd_sc_hd__decap_3
Xoutput491 _3741_/B VGND VGND VPWR VPWR alu_result_out[6] sky130_fd_sc_hd__clkdlybuf4s25_1
XPHY_EDGE_ROW_110_Right_110 VGND VGND VPWR VPWR sky130_fd_sc_hd__decap_3
XFILLER_101_460 VGND VGND VPWR VPWR sky130_fd_sc_hd__decap_3
XFILLER_59_352 VGND VGND VPWR VPWR sky130_fd_sc_hd__fill_2
XFILLER_87_650 VGND VGND VPWR VPWR sky130_fd_sc_hd__decap_3
XFILLER_93_119 VGND VGND VPWR VPWR sky130_fd_sc_hd__fill_2
XFILLER_59_396 VGND VGND VPWR VPWR sky130_fd_sc_hd__decap_3
XFILLER_74_333 VGND VGND VPWR VPWR sky130_fd_sc_hd__decap_3
XFILLER_86_160 VGND VGND VPWR VPWR sky130_fd_sc_hd__fill_2
XFILLER_47_86 VGND VGND VPWR VPWR sky130_fd_sc_hd__decap_3
XFILLER_27_260 VGND VGND VPWR VPWR sky130_fd_sc_hd__decap_3
XFILLER_103_81 VGND VGND VPWR VPWR sky130_fd_sc_hd__decap_3
XFILLER_103_92 VGND VGND VPWR VPWR sky130_fd_sc_hd__decap_3
XFILLER_15_433 VGND VGND VPWR VPWR sky130_fd_sc_hd__decap_3
XFILLER_15_444 VGND VGND VPWR VPWR sky130_fd_sc_hd__decap_3
XFILLER_27_293 VGND VGND VPWR VPWR sky130_fd_sc_hd__decap_3
XFILLER_55_591 VGND VGND VPWR VPWR sky130_fd_sc_hd__decap_3
XFILLER_15_499 VGND VGND VPWR VPWR sky130_fd_sc_hd__decap_3
XFILLER_42_296 VGND VGND VPWR VPWR sky130_fd_sc_hd__fill_1
XFILLER_8_14 VGND VGND VPWR VPWR sky130_fd_sc_hd__decap_3
XFILLER_8_47 VGND VGND VPWR VPWR sky130_fd_sc_hd__decap_3
XFILLER_11_661 VGND VGND VPWR VPWR sky130_fd_sc_hd__decap_3
XFILLER_7_610 VGND VGND VPWR VPWR sky130_fd_sc_hd__decap_3
XFILLER_116_519 VGND VGND VPWR VPWR sky130_fd_sc_hd__decap_3
XFILLER_6_153 VGND VGND VPWR VPWR sky130_fd_sc_hd__decap_3
XFILLER_7_654 VGND VGND VPWR VPWR sky130_fd_sc_hd__decap_3
XFILLER_7_676 VGND VGND VPWR VPWR sky130_fd_sc_hd__decap_3
XFILLER_109_582 VGND VGND VPWR VPWR sky130_fd_sc_hd__decap_3
XFILLER_40_6 VGND VGND VPWR VPWR sky130_fd_sc_hd__decap_3
XFILLER_6_197 VGND VGND VPWR VPWR sky130_fd_sc_hd__fill_1
XFILLER_111_202 VGND VGND VPWR VPWR sky130_fd_sc_hd__decap_3
XFILLER_69_105 VGND VGND VPWR VPWR sky130_fd_sc_hd__decap_3
XFILLER_69_116 VGND VGND VPWR VPWR sky130_fd_sc_hd__fill_2
XFILLER_88_60 VGND VGND VPWR VPWR sky130_fd_sc_hd__decap_3
XTAP_TAPCELL_ROW_90_1327 VGND VPWR sky130_fd_sc_hd__tapvpwrvgnd_1
XFILLER_2_392 VGND VGND VPWR VPWR sky130_fd_sc_hd__decap_3
XFILLER_69_127 VGND VGND VPWR VPWR sky130_fd_sc_hd__decap_3
XFILLER_97_458 VGND VGND VPWR VPWR sky130_fd_sc_hd__decap_3
XFILLER_78_672 VGND VGND VPWR VPWR sky130_fd_sc_hd__decap_3
XFILLER_84_108 VGND VGND VPWR VPWR sky130_fd_sc_hd__decap_3
XFILLER_38_536 VGND VGND VPWR VPWR sky130_fd_sc_hd__fill_1
XFILLER_65_322 VGND VGND VPWR VPWR sky130_fd_sc_hd__decap_3
XFILLER_77_160 VGND VGND VPWR VPWR sky130_fd_sc_hd__decap_3
XFILLER_93_620 VGND VGND VPWR VPWR sky130_fd_sc_hd__decap_3
XFILLER_65_355 VGND VGND VPWR VPWR sky130_fd_sc_hd__fill_2
XFILLER_65_366 VGND VGND VPWR VPWR sky130_fd_sc_hd__decap_3
XFILLER_92_130 VGND VGND VPWR VPWR sky130_fd_sc_hd__decap_3
XFILLER_93_653 VGND VGND VPWR VPWR sky130_fd_sc_hd__decap_3
X_6990_ _7337_/CLK _6990_/D _6270_/Y VGND VGND VPWR VPWR _6990_/Q sky130_fd_sc_hd__dfrtp_2
XFILLER_25_208 VGND VGND VPWR VPWR sky130_fd_sc_hd__fill_1
XFILLER_25_219 VGND VGND VPWR VPWR sky130_fd_sc_hd__decap_3
XFILLER_65_399 VGND VGND VPWR VPWR sky130_fd_sc_hd__decap_3
XFILLER_18_282 VGND VGND VPWR VPWR sky130_fd_sc_hd__decap_3
XFILLER_80_358 VGND VGND VPWR VPWR sky130_fd_sc_hd__decap_3
XFILLER_33_263 VGND VGND VPWR VPWR sky130_fd_sc_hd__decap_3
XFILLER_61_561 VGND VGND VPWR VPWR sky130_fd_sc_hd__decap_3
XFILLER_21_425 VGND VGND VPWR VPWR sky130_fd_sc_hd__fill_2
X_4823_ _4823_/A0 _4822_/X _4901_/S VGND VGND VPWR VPWR _7272_/D sky130_fd_sc_hd__mux2_2
XTAP_TAPCELL_ROW_44_781 VGND VPWR sky130_fd_sc_hd__tapvpwrvgnd_1
XFILLER_21_458 VGND VGND VPWR VPWR sky130_fd_sc_hd__decap_3
XFILLER_21_469 VGND VGND VPWR VPWR sky130_fd_sc_hd__decap_3
X_3705_ _3705_/A0 _3704_/X _3757_/S VGND VGND VPWR VPWR _7400_/D sky130_fd_sc_hd__mux2_2
XFILLER_107_508 VGND VGND VPWR VPWR sky130_fd_sc_hd__decap_3
X_4685_ _6996_/Q _4668_/X _4928_/B _4684_/X VGND VGND VPWR VPWR _4858_/B sky130_fd_sc_hd__a31o_2
XFILLER_108_15 VGND VGND VPWR VPWR sky130_fd_sc_hd__decap_3
X_6424_ _6675_/A VGND VGND VPWR VPWR _6424_/Y sky130_fd_sc_hd__inv_2
X_3636_ _3636_/A _3636_/B VGND VGND VPWR VPWR _3636_/Y sky130_fd_sc_hd__nor2_2
XFILLER_108_59 VGND VGND VPWR VPWR sky130_fd_sc_hd__decap_3
XFILLER_115_541 VGND VGND VPWR VPWR sky130_fd_sc_hd__decap_3
X_6355_ _6385_/A VGND VGND VPWR VPWR _6355_/Y sky130_fd_sc_hd__inv_2
X_3567_ _7221_/Q _4331_/A2 _4534_/S _7034_/Q _3566_/X VGND VGND VPWR VPWR _3567_/X
+ sky130_fd_sc_hd__a221o_2
XFILLER_0_318 VGND VGND VPWR VPWR sky130_fd_sc_hd__decap_3
XFILLER_115_585 VGND VGND VPWR VPWR sky130_fd_sc_hd__decap_3
X_6286_ _6288_/A VGND VGND VPWR VPWR _6286_/Y sky130_fd_sc_hd__inv_2
X_5306_ _5306_/A0 _4806_/X _5315_/S VGND VGND VPWR VPWR _7177_/D sky130_fd_sc_hd__mux2_2
XFILLER_88_436 VGND VGND VPWR VPWR sky130_fd_sc_hd__decap_3
X_3498_ _3442_/A _3442_/B _3449_/B VGND VGND VPWR VPWR _5152_/B sky130_fd_sc_hd__a21oi_2
XFILLER_102_268 VGND VGND VPWR VPWR sky130_fd_sc_hd__decap_3
XFILLER_69_650 VGND VGND VPWR VPWR sky130_fd_sc_hd__decap_3
XTAP_TAPCELL_ROW_110_1574 VGND VPWR sky130_fd_sc_hd__tapvpwrvgnd_1
XFILLER_84_18 VGND VGND VPWR VPWR sky130_fd_sc_hd__decap_3
XFILLER_84_29 VGND VGND VPWR VPWR sky130_fd_sc_hd__decap_3
XFILLER_84_631 VGND VGND VPWR VPWR sky130_fd_sc_hd__decap_3
XFILLER_96_480 VGND VGND VPWR VPWR sky130_fd_sc_hd__decap_3
XFILLER_17_12 VGND VGND VPWR VPWR sky130_fd_sc_hd__decap_3
XFILLER_68_193 VGND VGND VPWR VPWR sky130_fd_sc_hd__decap_3
X_5099_ _5099_/A _5100_/A VGND VGND VPWR VPWR _5099_/X sky130_fd_sc_hd__or2_2
X_4119_ _7236_/Q _4469_/A3 _4196_/A2 _7396_/Q _4118_/X VGND VGND VPWR VPWR _4119_/X
+ sky130_fd_sc_hd__a221o_2
XFILLER_44_528 VGND VGND VPWR VPWR sky130_fd_sc_hd__decap_3
XFILLER_83_152 VGND VGND VPWR VPWR sky130_fd_sc_hd__decap_3
XFILLER_84_675 VGND VGND VPWR VPWR sky130_fd_sc_hd__decap_3
XFILLER_17_78 VGND VGND VPWR VPWR sky130_fd_sc_hd__decap_3
XTAP_TAPCELL_ROW_65_1031 VGND VPWR sky130_fd_sc_hd__tapvpwrvgnd_1
XFILLER_24_230 VGND VGND VPWR VPWR sky130_fd_sc_hd__decap_3
XFILLER_24_274 VGND VGND VPWR VPWR sky130_fd_sc_hd__decap_3
XFILLER_52_583 VGND VGND VPWR VPWR sky130_fd_sc_hd__decap_3
XFILLER_4_635 VGND VGND VPWR VPWR sky130_fd_sc_hd__decap_3
XFILLER_106_530 VGND VGND VPWR VPWR sky130_fd_sc_hd__fill_2
XFILLER_3_134 VGND VGND VPWR VPWR sky130_fd_sc_hd__decap_3
XFILLER_4_657 VGND VGND VPWR VPWR sky130_fd_sc_hd__decap_3
XTAP_TAPCELL_ROW_76_1160 VGND VPWR sky130_fd_sc_hd__tapvpwrvgnd_1
XFILLER_79_436 VGND VGND VPWR VPWR sky130_fd_sc_hd__decap_3
XFILLER_58_41 VGND VGND VPWR VPWR sky130_fd_sc_hd__decap_3
XFILLER_66_108 VGND VGND VPWR VPWR sky130_fd_sc_hd__decap_3
XFILLER_67_609 VGND VGND VPWR VPWR sky130_fd_sc_hd__decap_3
XFILLER_94_417 VGND VGND VPWR VPWR sky130_fd_sc_hd__decap_3
XFILLER_47_311 VGND VGND VPWR VPWR sky130_fd_sc_hd__decap_3
XFILLER_58_85 VGND VGND VPWR VPWR sky130_fd_sc_hd__decap_3
XFILLER_59_160 VGND VGND VPWR VPWR sky130_fd_sc_hd__decap_3
XFILLER_75_620 VGND VGND VPWR VPWR sky130_fd_sc_hd__fill_1
XFILLER_101_290 VGND VGND VPWR VPWR sky130_fd_sc_hd__decap_3
XFILLER_59_193 VGND VGND VPWR VPWR sky130_fd_sc_hd__decap_3
XFILLER_74_141 VGND VGND VPWR VPWR sky130_fd_sc_hd__decap_3
XFILLER_75_642 VGND VGND VPWR VPWR sky130_fd_sc_hd__decap_3
XFILLER_114_80 VGND VGND VPWR VPWR sky130_fd_sc_hd__decap_3
XFILLER_114_91 VGND VGND VPWR VPWR sky130_fd_sc_hd__decap_3
XFILLER_74_163 VGND VGND VPWR VPWR sky130_fd_sc_hd__decap_3
XFILLER_74_51 VGND VGND VPWR VPWR sky130_fd_sc_hd__decap_3
XFILLER_47_399 VGND VGND VPWR VPWR sky130_fd_sc_hd__decap_3
XFILLER_62_325 VGND VGND VPWR VPWR sky130_fd_sc_hd__decap_3
XFILLER_74_185 VGND VGND VPWR VPWR sky130_fd_sc_hd__decap_3
XFILLER_74_73 VGND VGND VPWR VPWR sky130_fd_sc_hd__fill_2
XFILLER_90_634 VGND VGND VPWR VPWR sky130_fd_sc_hd__decap_3
XFILLER_90_645 VGND VGND VPWR VPWR sky130_fd_sc_hd__decap_3
XFILLER_90_678 VGND VGND VPWR VPWR sky130_fd_sc_hd__decap_3
XFILLER_15_263 VGND VGND VPWR VPWR sky130_fd_sc_hd__decap_3
XFILLER_15_296 VGND VGND VPWR VPWR sky130_fd_sc_hd__decap_3
XFILLER_70_380 VGND VGND VPWR VPWR sky130_fd_sc_hd__decap_3
XFILLER_88_6 VGND VGND VPWR VPWR sky130_fd_sc_hd__decap_3
XFILLER_90_61 VGND VGND VPWR VPWR sky130_fd_sc_hd__decap_3
XTAP_TAPCELL_ROW_41_740 VGND VPWR sky130_fd_sc_hd__tapvpwrvgnd_1
XFILLER_90_94 VGND VGND VPWR VPWR sky130_fd_sc_hd__decap_3
XFILLER_7_440 VGND VGND VPWR VPWR sky130_fd_sc_hd__decap_3
XFILLER_116_327 VGND VGND VPWR VPWR sky130_fd_sc_hd__decap_3
X_4470_ _3346_/A _3927_/X _4466_/Y _4469_/X VGND VGND VPWR VPWR _4470_/X sky130_fd_sc_hd__a31o_2
XFILLER_109_390 VGND VGND VPWR VPWR sky130_fd_sc_hd__fill_2
X_3421_ _4537_/B _3421_/B _3421_/C VGND VGND VPWR VPWR _4289_/B sky130_fd_sc_hd__or3_4
XFILLER_99_81 VGND VGND VPWR VPWR sky130_fd_sc_hd__decap_3
X_3352_ _3420_/A _5642_/B VGND VGND VPWR VPWR _3469_/B sky130_fd_sc_hd__nor2_2
XFILLER_112_533 VGND VGND VPWR VPWR sky130_fd_sc_hd__decap_3
XFILLER_97_211 VGND VGND VPWR VPWR sky130_fd_sc_hd__decap_3
XFILLER_112_566 VGND VGND VPWR VPWR sky130_fd_sc_hd__decap_3
XFILLER_97_266 VGND VGND VPWR VPWR sky130_fd_sc_hd__decap_3
XFILLER_66_631 VGND VGND VPWR VPWR sky130_fd_sc_hd__decap_3
XFILLER_78_480 VGND VGND VPWR VPWR sky130_fd_sc_hd__decap_3
XFILLER_97_299 VGND VGND VPWR VPWR sky130_fd_sc_hd__decap_3
Xhold1107 _7308_/Q VGND VGND VPWR VPWR _4544_/A sky130_fd_sc_hd__dlygate4sd3_1
Xhold1118 _7251_/Q VGND VGND VPWR VPWR _5136_/A0 sky130_fd_sc_hd__dlygate4sd3_1
Xhold1129 _7172_/Q VGND VGND VPWR VPWR _5317_/A0 sky130_fd_sc_hd__dlygate4sd3_1
X_5022_ _3548_/X _5017_/Y _5020_/X _5021_/X VGND VGND VPWR VPWR _5661_/A sky130_fd_sc_hd__o211a_2
Xsingle_cycle_cpu_581 VGND VGND VPWR VPWR instruction_out[0] single_cycle_cpu_581/LO
+ sky130_fd_sc_hd__conb_1
XTAP_TAPCELL_ROW_49_840 VGND VPWR sky130_fd_sc_hd__tapvpwrvgnd_1
XFILLER_38_388 VGND VGND VPWR VPWR sky130_fd_sc_hd__decap_3
XFILLER_66_675 VGND VGND VPWR VPWR sky130_fd_sc_hd__decap_3
XFILLER_81_601 VGND VGND VPWR VPWR sky130_fd_sc_hd__decap_3
XFILLER_81_623 VGND VGND VPWR VPWR sky130_fd_sc_hd__decap_3
XFILLER_93_461 VGND VGND VPWR VPWR sky130_fd_sc_hd__decap_3
XFILLER_53_325 VGND VGND VPWR VPWR sky130_fd_sc_hd__fill_2
XFILLER_65_196 VGND VGND VPWR VPWR sky130_fd_sc_hd__decap_3
XFILLER_80_111 VGND VGND VPWR VPWR sky130_fd_sc_hd__decap_3
XFILLER_81_656 VGND VGND VPWR VPWR sky130_fd_sc_hd__decap_3
X_6973_ _6978_/CLK _6973_/D VGND VGND VPWR VPWR _6973_/Q sky130_fd_sc_hd__dfxtp_2
XFILLER_0_92 VGND VGND VPWR VPWR sky130_fd_sc_hd__decap_3
XFILLER_80_144 VGND VGND VPWR VPWR sky130_fd_sc_hd__decap_3
XFILLER_80_166 VGND VGND VPWR VPWR sky130_fd_sc_hd__decap_3
XFILLER_110_27 VGND VGND VPWR VPWR sky130_fd_sc_hd__fill_1
XFILLER_110_38 VGND VGND VPWR VPWR sky130_fd_sc_hd__decap_3
XFILLER_34_583 VGND VGND VPWR VPWR sky130_fd_sc_hd__decap_3
XFILLER_21_255 VGND VGND VPWR VPWR sky130_fd_sc_hd__fill_1
X_4806_ _3346_/A _3701_/X _4799_/X _4805_/X VGND VGND VPWR VPWR _4806_/X sky130_fd_sc_hd__a31o_2
XFILLER_21_266 VGND VGND VPWR VPWR sky130_fd_sc_hd__decap_3
XFILLER_9_90 VGND VGND VPWR VPWR sky130_fd_sc_hd__decap_3
XFILLER_21_299 VGND VGND VPWR VPWR sky130_fd_sc_hd__decap_3
X_4737_ _7005_/Q _4775_/A _7006_/Q VGND VGND VPWR VPWR _4738_/B sky130_fd_sc_hd__a21oi_2
XFILLER_107_327 VGND VGND VPWR VPWR sky130_fd_sc_hd__decap_3
X_4668_ _4908_/A _4896_/A VGND VGND VPWR VPWR _4668_/X sky130_fd_sc_hd__and2_2
XFILLER_79_29 VGND VGND VPWR VPWR sky130_fd_sc_hd__decap_3
Xhold930 _7031_/Q VGND VGND VPWR VPWR _5593_/A sky130_fd_sc_hd__dlygate4sd3_1
X_6407_ _6570_/A VGND VGND VPWR VPWR _6407_/Y sky130_fd_sc_hd__inv_2
X_3619_ _3620_/A _3620_/C _4292_/B VGND VGND VPWR VPWR _3619_/Y sky130_fd_sc_hd__o21ai_2
X_7387_ _7387_/CLK _7387_/D _6667_/Y VGND VGND VPWR VPWR _7387_/Q sky130_fd_sc_hd__dfrtp_2
Xhold963 _7398_/Q VGND VGND VPWR VPWR hold963/X sky130_fd_sc_hd__dlygate4sd3_1
Xhold952 _6694_/Q VGND VGND VPWR VPWR hold952/X sky130_fd_sc_hd__dlygate4sd3_1
Xhold941 _7028_/Q VGND VGND VPWR VPWR hold941/X sky130_fd_sc_hd__dlygate4sd3_1
X_4599_ _7281_/Q _5142_/A0 _4601_/S VGND VGND VPWR VPWR _7281_/D sky130_fd_sc_hd__mux2_2
XFILLER_0_104 VGND VGND VPWR VPWR sky130_fd_sc_hd__decap_3
XFILLER_0_126 VGND VGND VPWR VPWR sky130_fd_sc_hd__decap_3
XFILLER_1_649 VGND VGND VPWR VPWR sky130_fd_sc_hd__decap_3
Xhold996 _7017_/Q VGND VGND VPWR VPWR _5621_/A sky130_fd_sc_hd__dlygate4sd3_1
Xhold985 _7375_/Q VGND VGND VPWR VPWR hold985/X sky130_fd_sc_hd__dlygate4sd3_1
Xhold974 _7392_/Q VGND VGND VPWR VPWR hold974/X sky130_fd_sc_hd__dlygate4sd3_1
X_6338_ _6568_/A VGND VGND VPWR VPWR _6338_/Y sky130_fd_sc_hd__inv_2
XFILLER_103_555 VGND VGND VPWR VPWR sky130_fd_sc_hd__fill_2
XFILLER_49_609 VGND VGND VPWR VPWR sky130_fd_sc_hd__decap_3
XFILLER_76_417 VGND VGND VPWR VPWR sky130_fd_sc_hd__decap_3
X_6269_ _6553_/A VGND VGND VPWR VPWR _6269_/Y sky130_fd_sc_hd__inv_2
XFILLER_103_588 VGND VGND VPWR VPWR sky130_fd_sc_hd__decap_3
XFILLER_57_620 VGND VGND VPWR VPWR sky130_fd_sc_hd__decap_3
XFILLER_76_439 VGND VGND VPWR VPWR sky130_fd_sc_hd__decap_3
XFILLER_29_322 VGND VGND VPWR VPWR sky130_fd_sc_hd__decap_3
XFILLER_29_355 VGND VGND VPWR VPWR sky130_fd_sc_hd__fill_2
XFILLER_57_653 VGND VGND VPWR VPWR sky130_fd_sc_hd__decap_3
XFILLER_91_409 VGND VGND VPWR VPWR sky130_fd_sc_hd__decap_3
XFILLER_56_141 VGND VGND VPWR VPWR sky130_fd_sc_hd__fill_1
XFILLER_56_152 VGND VGND VPWR VPWR sky130_fd_sc_hd__decap_3
XFILLER_56_174 VGND VGND VPWR VPWR sky130_fd_sc_hd__decap_3
XFILLER_84_483 VGND VGND VPWR VPWR sky130_fd_sc_hd__decap_3
XFILLER_72_645 VGND VGND VPWR VPWR sky130_fd_sc_hd__decap_3
XFILLER_84_494 VGND VGND VPWR VPWR sky130_fd_sc_hd__decap_3
XFILLER_44_21 VGND VGND VPWR VPWR sky130_fd_sc_hd__decap_3
XFILLER_44_32 VGND VGND VPWR VPWR sky130_fd_sc_hd__decap_3
XFILLER_44_43 VGND VGND VPWR VPWR sky130_fd_sc_hd__decap_3
XFILLER_71_144 VGND VGND VPWR VPWR sky130_fd_sc_hd__decap_3
XFILLER_72_678 VGND VGND VPWR VPWR sky130_fd_sc_hd__decap_3
XTAP_TAPCELL_ROW_27_578 VGND VPWR sky130_fd_sc_hd__tapvpwrvgnd_1
XFILLER_12_200 VGND VGND VPWR VPWR sky130_fd_sc_hd__decap_3
XFILLER_40_520 VGND VGND VPWR VPWR sky130_fd_sc_hd__fill_2
XFILLER_44_76 VGND VGND VPWR VPWR sky130_fd_sc_hd__fill_1
XFILLER_71_199 VGND VGND VPWR VPWR sky130_fd_sc_hd__fill_2
XFILLER_40_542 VGND VGND VPWR VPWR sky130_fd_sc_hd__decap_3
XFILLER_12_277 VGND VGND VPWR VPWR sky130_fd_sc_hd__decap_3
XFILLER_60_42 VGND VGND VPWR VPWR sky130_fd_sc_hd__decap_3
XFILLER_8_259 VGND VGND VPWR VPWR sky130_fd_sc_hd__fill_1
XFILLER_4_421 VGND VGND VPWR VPWR sky130_fd_sc_hd__decap_3
XFILLER_5_15 VGND VGND VPWR VPWR sky130_fd_sc_hd__decap_3
XFILLER_4_454 VGND VGND VPWR VPWR sky130_fd_sc_hd__decap_3
XFILLER_5_48 VGND VGND VPWR VPWR sky130_fd_sc_hd__decap_3
XFILLER_106_371 VGND VGND VPWR VPWR sky130_fd_sc_hd__decap_3
XFILLER_69_84 VGND VGND VPWR VPWR sky130_fd_sc_hd__decap_3
XFILLER_67_406 VGND VGND VPWR VPWR sky130_fd_sc_hd__decap_3
XFILLER_79_255 VGND VGND VPWR VPWR sky130_fd_sc_hd__fill_1
XFILLER_0_660 VGND VGND VPWR VPWR sky130_fd_sc_hd__fill_2
XFILLER_39_108 VGND VGND VPWR VPWR sky130_fd_sc_hd__decap_3
XFILLER_79_277 VGND VGND VPWR VPWR sky130_fd_sc_hd__decap_3
XFILLER_94_203 VGND VGND VPWR VPWR sky130_fd_sc_hd__decap_3
XFILLER_48_631 VGND VGND VPWR VPWR sky130_fd_sc_hd__decap_3
XPHY_EDGE_ROW_13_Right_13 VGND VGND VPWR VPWR sky130_fd_sc_hd__decap_3
XFILLER_47_163 VGND VGND VPWR VPWR sky130_fd_sc_hd__decap_3
XFILLER_48_675 VGND VGND VPWR VPWR sky130_fd_sc_hd__decap_3
XFILLER_63_601 VGND VGND VPWR VPWR sky130_fd_sc_hd__decap_3
XFILLER_63_623 VGND VGND VPWR VPWR sky130_fd_sc_hd__decap_3
XFILLER_47_196 VGND VGND VPWR VPWR sky130_fd_sc_hd__decap_3
XFILLER_62_122 VGND VGND VPWR VPWR sky130_fd_sc_hd__decap_3
XFILLER_63_656 VGND VGND VPWR VPWR sky130_fd_sc_hd__decap_3
XFILLER_16_550 VGND VGND VPWR VPWR sky130_fd_sc_hd__fill_1
XFILLER_35_358 VGND VGND VPWR VPWR sky130_fd_sc_hd__decap_3
XFILLER_62_144 VGND VGND VPWR VPWR sky130_fd_sc_hd__decap_3
X_3970_ _7355_/Q _4513_/A0 _3987_/S VGND VGND VPWR VPWR _7355_/D sky130_fd_sc_hd__mux2_2
XFILLER_31_520 VGND VGND VPWR VPWR sky130_fd_sc_hd__fill_1
XFILLER_86_3 VGND VGND VPWR VPWR sky130_fd_sc_hd__decap_3
X_5640_ _5640_/A _5640_/B VGND VGND VPWR VPWR _5640_/Y sky130_fd_sc_hd__nor2_2
XFILLER_31_597 VGND VGND VPWR VPWR sky130_fd_sc_hd__decap_3
X_5571_ hold964/X _4909_/A _4944_/C VGND VGND VPWR VPWR _7046_/D sky130_fd_sc_hd__a21o_2
XPHY_EDGE_ROW_22_Right_22 VGND VGND VPWR VPWR sky130_fd_sc_hd__decap_3
XFILLER_116_113 VGND VGND VPWR VPWR sky130_fd_sc_hd__decap_3
X_7310_ _7310_/CLK _7310_/D _6590_/Y VGND VGND VPWR VPWR _7310_/Q sky130_fd_sc_hd__dfrtp_2
X_4522_ _7318_/Q _7286_/Q _4522_/S VGND VGND VPWR VPWR _7318_/D sky130_fd_sc_hd__mux2_2
XFILLER_116_135 VGND VGND VPWR VPWR sky130_fd_sc_hd__decap_3
XFILLER_7_281 VGND VGND VPWR VPWR sky130_fd_sc_hd__decap_3
X_7241_ _7337_/CLK _7241_/D _6521_/Y VGND VGND VPWR VPWR _7241_/Q sky130_fd_sc_hd__dfrtp_2
X_4453_ _4453_/A VGND VGND VPWR VPWR _4762_/B sky130_fd_sc_hd__inv_2
XTAP_TAPCELL_ROW_96_1399 VGND VPWR sky130_fd_sc_hd__tapvpwrvgnd_1
X_7172_ _7397_/CLK _7172_/D _6452_/Y VGND VGND VPWR VPWR _7172_/Q sky130_fd_sc_hd__dfrtp_2
X_4384_ _4384_/A _4968_/A _4384_/C VGND VGND VPWR VPWR _4778_/B sky130_fd_sc_hd__nand3_2
XFILLER_98_542 VGND VGND VPWR VPWR sky130_fd_sc_hd__decap_3
X_3335_ _3319_/X _5238_/B _3329_/Y _3339_/C1 VGND VGND VPWR VPWR _3442_/A sky130_fd_sc_hd__a211o_2
XFILLER_105_27 VGND VGND VPWR VPWR sky130_fd_sc_hd__decap_3
XFILLER_112_363 VGND VGND VPWR VPWR sky130_fd_sc_hd__fill_1
XFILLER_39_620 VGND VGND VPWR VPWR sky130_fd_sc_hd__decap_3
XFILLER_85_225 VGND VGND VPWR VPWR sky130_fd_sc_hd__decap_3
XPHY_EDGE_ROW_31_Right_31 VGND VGND VPWR VPWR sky130_fd_sc_hd__decap_3
X_5005_ _5004_/A _5004_/B _5020_/A VGND VGND VPWR VPWR _5005_/Y sky130_fd_sc_hd__a21oi_2
XFILLER_38_141 VGND VGND VPWR VPWR sky130_fd_sc_hd__decap_3
XFILLER_54_601 VGND VGND VPWR VPWR sky130_fd_sc_hd__decap_3
XFILLER_66_461 VGND VGND VPWR VPWR sky130_fd_sc_hd__decap_3
XFILLER_38_185 VGND VGND VPWR VPWR sky130_fd_sc_hd__decap_3
XFILLER_54_634 VGND VGND VPWR VPWR sky130_fd_sc_hd__decap_3
XFILLER_54_645 VGND VGND VPWR VPWR sky130_fd_sc_hd__decap_3
XFILLER_53_155 VGND VGND VPWR VPWR sky130_fd_sc_hd__decap_3
XFILLER_54_678 VGND VGND VPWR VPWR sky130_fd_sc_hd__decap_3
X_6956_ _6971_/CLK _6956_/D VGND VGND VPWR VPWR _6956_/Q sky130_fd_sc_hd__dfxtp_2
XTAP_TAPCELL_ROW_62_1001 VGND VPWR sky130_fd_sc_hd__tapvpwrvgnd_1
XFILLER_14_24 VGND VGND VPWR VPWR sky130_fd_sc_hd__decap_3
XFILLER_14_35 VGND VGND VPWR VPWR sky130_fd_sc_hd__decap_3
XFILLER_34_380 VGND VGND VPWR VPWR sky130_fd_sc_hd__decap_3
X_6887_ _7005_/CLK _6887_/D VGND VGND VPWR VPWR _6887_/Q sky130_fd_sc_hd__dfxtp_2
XTAP_TAPCELL_ROW_24_537 VGND VPWR sky130_fd_sc_hd__tapvpwrvgnd_1
XFILLER_14_68 VGND VGND VPWR VPWR sky130_fd_sc_hd__decap_3
XFILLER_22_586 VGND VGND VPWR VPWR sky130_fd_sc_hd__fill_2
XTAP_TAPCELL_ROW_52_879 VGND VPWR sky130_fd_sc_hd__tapvpwrvgnd_1
XPHY_EDGE_ROW_40_Right_40 VGND VGND VPWR VPWR sky130_fd_sc_hd__decap_3
XFILLER_107_102 VGND VGND VPWR VPWR sky130_fd_sc_hd__decap_3
XFILLER_108_625 VGND VGND VPWR VPWR sky130_fd_sc_hd__decap_3
XFILLER_107_113 VGND VGND VPWR VPWR sky130_fd_sc_hd__decap_3
XFILLER_107_146 VGND VGND VPWR VPWR sky130_fd_sc_hd__decap_3
XFILLER_108_669 VGND VGND VPWR VPWR sky130_fd_sc_hd__decap_3
XFILLER_30_56 VGND VGND VPWR VPWR sky130_fd_sc_hd__decap_3
XFILLER_1_402 VGND VGND VPWR VPWR sky130_fd_sc_hd__decap_3
Xhold760 _6900_/Q VGND VGND VPWR VPWR _6900_/D sky130_fd_sc_hd__dlygate4sd3_1
Xhold771 _6974_/Q VGND VGND VPWR VPWR _6974_/D sky130_fd_sc_hd__dlygate4sd3_1
Xhold782 _6931_/Q VGND VGND VPWR VPWR _6931_/D sky130_fd_sc_hd__dlygate4sd3_1
XTAP_TAPCELL_ROW_73_1130 VGND VPWR sky130_fd_sc_hd__tapvpwrvgnd_1
XFILLER_115_190 VGND VGND VPWR VPWR sky130_fd_sc_hd__decap_3
XFILLER_89_542 VGND VGND VPWR VPWR sky130_fd_sc_hd__decap_3
Xhold793 _6726_/Q VGND VGND VPWR VPWR _6726_/D sky130_fd_sc_hd__dlygate4sd3_1
XFILLER_103_385 VGND VGND VPWR VPWR sky130_fd_sc_hd__decap_3
XFILLER_49_428 VGND VGND VPWR VPWR sky130_fd_sc_hd__decap_3
XFILLER_76_203 VGND VGND VPWR VPWR sky130_fd_sc_hd__fill_1
XFILLER_45_601 VGND VGND VPWR VPWR sky130_fd_sc_hd__decap_3
XFILLER_29_196 VGND VGND VPWR VPWR sky130_fd_sc_hd__decap_3
XFILLER_45_623 VGND VGND VPWR VPWR sky130_fd_sc_hd__decap_3
XFILLER_55_42 VGND VGND VPWR VPWR sky130_fd_sc_hd__fill_2
XFILLER_91_239 VGND VGND VPWR VPWR sky130_fd_sc_hd__decap_3
XTAP_TAPCELL_ROW_4_295 VGND VPWR sky130_fd_sc_hd__tapvpwrvgnd_1
XFILLER_17_369 VGND VGND VPWR VPWR sky130_fd_sc_hd__fill_1
XFILLER_44_144 VGND VGND VPWR VPWR sky130_fd_sc_hd__fill_2
XFILLER_45_667 VGND VGND VPWR VPWR sky130_fd_sc_hd__decap_3
XFILLER_55_75 VGND VGND VPWR VPWR sky130_fd_sc_hd__decap_3
XFILLER_60_604 VGND VGND VPWR VPWR sky130_fd_sc_hd__decap_3
XFILLER_60_637 VGND VGND VPWR VPWR sky130_fd_sc_hd__decap_3
XFILLER_60_648 VGND VGND VPWR VPWR sky130_fd_sc_hd__decap_3
XFILLER_111_81 VGND VGND VPWR VPWR sky130_fd_sc_hd__decap_3
XFILLER_25_380 VGND VGND VPWR VPWR sky130_fd_sc_hd__decap_3
XFILLER_71_30 VGND VGND VPWR VPWR sky130_fd_sc_hd__decap_3
XFILLER_13_564 VGND VGND VPWR VPWR sky130_fd_sc_hd__decap_3
XFILLER_71_41 VGND VGND VPWR VPWR sky130_fd_sc_hd__decap_3
XFILLER_71_74 VGND VGND VPWR VPWR sky130_fd_sc_hd__decap_3
XFILLER_72_9 VGND VGND VPWR VPWR sky130_fd_sc_hd__decap_3
XFILLER_114_628 VGND VGND VPWR VPWR sky130_fd_sc_hd__decap_3
XFILLER_4_251 VGND VGND VPWR VPWR sky130_fd_sc_hd__fill_1
XFILLER_107_691 VGND VGND VPWR VPWR sky130_fd_sc_hd__fill_1
XFILLER_113_105 VGND VGND VPWR VPWR sky130_fd_sc_hd__decap_3
XFILLER_113_116 VGND VGND VPWR VPWR sky130_fd_sc_hd__decap_3
XFILLER_4_262 VGND VGND VPWR VPWR sky130_fd_sc_hd__decap_3
XFILLER_99_328 VGND VGND VPWR VPWR sky130_fd_sc_hd__decap_3
XFILLER_113_149 VGND VGND VPWR VPWR sky130_fd_sc_hd__decap_3
XFILLER_4_295 VGND VGND VPWR VPWR sky130_fd_sc_hd__decap_3
XFILLER_67_225 VGND VGND VPWR VPWR sky130_fd_sc_hd__decap_3
XFILLER_95_534 VGND VGND VPWR VPWR sky130_fd_sc_hd__decap_3
XFILLER_96_71 VGND VGND VPWR VPWR sky130_fd_sc_hd__fill_1
XFILLER_36_612 VGND VGND VPWR VPWR sky130_fd_sc_hd__decap_3
XFILLER_48_450 VGND VGND VPWR VPWR sky130_fd_sc_hd__fill_1
XFILLER_48_472 VGND VGND VPWR VPWR sky130_fd_sc_hd__decap_3
XFILLER_82_206 VGND VGND VPWR VPWR sky130_fd_sc_hd__decap_3
XFILLER_95_578 VGND VGND VPWR VPWR sky130_fd_sc_hd__decap_3
XFILLER_35_122 VGND VGND VPWR VPWR sky130_fd_sc_hd__decap_3
XFILLER_36_645 VGND VGND VPWR VPWR sky130_fd_sc_hd__decap_3
XFILLER_48_494 VGND VGND VPWR VPWR sky130_fd_sc_hd__decap_3
XFILLER_90_250 VGND VGND VPWR VPWR sky130_fd_sc_hd__fill_2
Xplace420 _4268_/A2 VGND VGND VPWR VPWR _3954_/S sky130_fd_sc_hd__buf_2
Xplace431 _3368_/Y VGND VGND VPWR VPWR _3394_/A sky130_fd_sc_hd__buf_2
X_6810_ _6975_/CLK _6810_/D VGND VGND VPWR VPWR _6810_/Q sky130_fd_sc_hd__dfxtp_2
XFILLER_36_689 VGND VGND VPWR VPWR sky130_fd_sc_hd__decap_3
XFILLER_51_626 VGND VGND VPWR VPWR sky130_fd_sc_hd__decap_3
XFILLER_90_283 VGND VGND VPWR VPWR sky130_fd_sc_hd__fill_1
Xplace442 _4667_/B VGND VGND VPWR VPWR _5634_/B sky130_fd_sc_hd__buf_2
Xplace453 _3342_/B VGND VGND VPWR VPWR _5129_/A sky130_fd_sc_hd__buf_2
XFILLER_35_199 VGND VGND VPWR VPWR sky130_fd_sc_hd__decap_3
XFILLER_51_659 VGND VGND VPWR VPWR sky130_fd_sc_hd__decap_3
X_6741_ _6909_/CLK _6741_/D VGND VGND VPWR VPWR _6741_/Q sky130_fd_sc_hd__dfxtp_2
XFILLER_31_361 VGND VGND VPWR VPWR sky130_fd_sc_hd__decap_3
XFILLER_50_158 VGND VGND VPWR VPWR sky130_fd_sc_hd__decap_3
X_6672_ _6672_/A VGND VGND VPWR VPWR _6672_/Y sky130_fd_sc_hd__inv_2
X_3884_ _6824_/Q _3884_/A2 _3884_/B1 _6809_/Q _3883_/X VGND VGND VPWR VPWR _3884_/X
+ sky130_fd_sc_hd__a221o_2
XTAP_TAPCELL_ROW_21_507 VGND VPWR sky130_fd_sc_hd__tapvpwrvgnd_1
XFILLER_31_383 VGND VGND VPWR VPWR sky130_fd_sc_hd__decap_3
XTAP_TAPCELL_ROW_98_1428 VGND VPWR sky130_fd_sc_hd__tapvpwrvgnd_1
XFILLER_105_617 VGND VGND VPWR VPWR sky130_fd_sc_hd__decap_3
X_4505_ _4505_/A0 _7295_/Q _4505_/S VGND VGND VPWR VPWR _4505_/X sky130_fd_sc_hd__mux2_2
XFILLER_6_80 VGND VGND VPWR VPWR sky130_fd_sc_hd__decap_3
XFILLER_6_91 VGND VGND VPWR VPWR sky130_fd_sc_hd__decap_3
X_7224_ clkload3/A _7224_/D _6504_/Y VGND VGND VPWR VPWR _7224_/Q sky130_fd_sc_hd__dfrtp_2
X_4436_ _7303_/Q _4901_/S _4436_/B1 _7175_/Q _4435_/X VGND VGND VPWR VPWR _4436_/X
+ sky130_fd_sc_hd__a221o_2
XFILLER_113_650 VGND VGND VPWR VPWR sky130_fd_sc_hd__decap_3
X_7155_ clkload3/A _7155_/D _6435_/Y VGND VGND VPWR VPWR _7155_/Q sky130_fd_sc_hd__dfrtp_2
X_4367_ _4367_/A _4367_/B _4367_/C VGND VGND VPWR VPWR _5054_/A sky130_fd_sc_hd__and3_2
XFILLER_100_300 VGND VGND VPWR VPWR sky130_fd_sc_hd__decap_3
XFILLER_58_203 VGND VGND VPWR VPWR sky130_fd_sc_hd__decap_3
XFILLER_86_501 VGND VGND VPWR VPWR sky130_fd_sc_hd__decap_3
X_3318_ _3403_/A _3318_/B VGND VGND VPWR VPWR _5647_/B sky130_fd_sc_hd__nand2_2
XFILLER_98_361 VGND VGND VPWR VPWR sky130_fd_sc_hd__decap_3
XFILLER_112_171 VGND VGND VPWR VPWR sky130_fd_sc_hd__decap_3
X_7086_ _7234_/CLK _7086_/D _6366_/Y VGND VGND VPWR VPWR _7086_/Q sky130_fd_sc_hd__dfrtp_2
X_4298_ _3620_/C _4292_/X _4293_/X _4297_/Y VGND VGND VPWR VPWR _4298_/X sky130_fd_sc_hd__a211o_2
XFILLER_98_394 VGND VGND VPWR VPWR sky130_fd_sc_hd__decap_3
XFILLER_100_377 VGND VGND VPWR VPWR sky130_fd_sc_hd__decap_3
XFILLER_86_589 VGND VGND VPWR VPWR sky130_fd_sc_hd__decap_3
XTAP_TAPCELL_ROW_57_938 VGND VPWR sky130_fd_sc_hd__tapvpwrvgnd_1
XFILLER_25_12 VGND VGND VPWR VPWR sky130_fd_sc_hd__decap_3
XFILLER_92_29 VGND VGND VPWR VPWR sky130_fd_sc_hd__fill_1
XTAP_TAPCELL_ROW_1_265 VGND VPWR sky130_fd_sc_hd__tapvpwrvgnd_1
XTAP_TAPCELL_ROW_107_1535 VGND VPWR sky130_fd_sc_hd__tapvpwrvgnd_1
XFILLER_26_166 VGND VGND VPWR VPWR sky130_fd_sc_hd__decap_3
XFILLER_26_188 VGND VGND VPWR VPWR sky130_fd_sc_hd__decap_3
XFILLER_42_615 VGND VGND VPWR VPWR sky130_fd_sc_hd__decap_3
XFILLER_25_78 VGND VGND VPWR VPWR sky130_fd_sc_hd__decap_3
XFILLER_41_125 VGND VGND VPWR VPWR sky130_fd_sc_hd__decap_3
XFILLER_42_659 VGND VGND VPWR VPWR sky130_fd_sc_hd__decap_3
X_6939_ _7005_/CLK _6939_/D VGND VGND VPWR VPWR _6939_/Q sky130_fd_sc_hd__dfxtp_2
XTAP_TAPCELL_ROW_37_695 VGND VPWR sky130_fd_sc_hd__tapvpwrvgnd_1
XFILLER_41_169 VGND VGND VPWR VPWR sky130_fd_sc_hd__decap_3
XFILLER_41_11 VGND VGND VPWR VPWR sky130_fd_sc_hd__decap_3
XFILLER_50_681 VGND VGND VPWR VPWR sky130_fd_sc_hd__decap_3
XFILLER_41_66 VGND VGND VPWR VPWR sky130_fd_sc_hd__decap_3
XFILLER_6_527 VGND VGND VPWR VPWR sky130_fd_sc_hd__decap_3
XFILLER_10_589 VGND VGND VPWR VPWR sky130_fd_sc_hd__fill_2
XFILLER_41_99 VGND VGND VPWR VPWR sky130_fd_sc_hd__decap_3
XFILLER_108_477 VGND VGND VPWR VPWR sky130_fd_sc_hd__fill_2
XFILLER_111_609 VGND VGND VPWR VPWR sky130_fd_sc_hd__decap_3
XFILLER_1_221 VGND VGND VPWR VPWR sky130_fd_sc_hd__decap_3
Xhold590 _6904_/Q VGND VGND VPWR VPWR _6904_/D sky130_fd_sc_hd__dlygate4sd3_1
XTAP_TAPCELL_ROW_9_365 VGND VPWR sky130_fd_sc_hd__tapvpwrvgnd_1
XTAP_TAPCELL_ROW_9_354 VGND VPWR sky130_fd_sc_hd__tapvpwrvgnd_1
XFILLER_104_672 VGND VGND VPWR VPWR sky130_fd_sc_hd__decap_3
XFILLER_77_501 VGND VGND VPWR VPWR sky130_fd_sc_hd__decap_3
XFILLER_89_372 VGND VGND VPWR VPWR sky130_fd_sc_hd__decap_3
XFILLER_2_38 VGND VGND VPWR VPWR sky130_fd_sc_hd__decap_3
XFILLER_49_236 VGND VGND VPWR VPWR sky130_fd_sc_hd__decap_3
XFILLER_64_206 VGND VGND VPWR VPWR sky130_fd_sc_hd__fill_2
XFILLER_66_63 VGND VGND VPWR VPWR sky130_fd_sc_hd__decap_3
XFILLER_92_504 VGND VGND VPWR VPWR sky130_fd_sc_hd__decap_3
XFILLER_18_634 VGND VGND VPWR VPWR sky130_fd_sc_hd__decap_3
XFILLER_18_645 VGND VGND VPWR VPWR sky130_fd_sc_hd__decap_3
XFILLER_64_217 VGND VGND VPWR VPWR sky130_fd_sc_hd__decap_3
XFILLER_64_228 VGND VGND VPWR VPWR sky130_fd_sc_hd__fill_2
XFILLER_64_239 VGND VGND VPWR VPWR sky130_fd_sc_hd__fill_1
XFILLER_66_85 VGND VGND VPWR VPWR sky130_fd_sc_hd__decap_3
XFILLER_92_548 VGND VGND VPWR VPWR sky130_fd_sc_hd__decap_3
XFILLER_17_166 VGND VGND VPWR VPWR sky130_fd_sc_hd__fill_2
XFILLER_17_188 VGND VGND VPWR VPWR sky130_fd_sc_hd__decap_3
XFILLER_32_103 VGND VGND VPWR VPWR sky130_fd_sc_hd__decap_3
XFILLER_33_615 VGND VGND VPWR VPWR sky130_fd_sc_hd__fill_1
XFILLER_45_475 VGND VGND VPWR VPWR sky130_fd_sc_hd__decap_3
XFILLER_45_486 VGND VGND VPWR VPWR sky130_fd_sc_hd__decap_3
XFILLER_32_125 VGND VGND VPWR VPWR sky130_fd_sc_hd__fill_1
XFILLER_32_147 VGND VGND VPWR VPWR sky130_fd_sc_hd__decap_3
XFILLER_33_659 VGND VGND VPWR VPWR sky130_fd_sc_hd__decap_3
XFILLER_72_294 VGND VGND VPWR VPWR sky130_fd_sc_hd__fill_1
XFILLER_82_62 VGND VGND VPWR VPWR sky130_fd_sc_hd__decap_3
XFILLER_20_309 VGND VGND VPWR VPWR sky130_fd_sc_hd__decap_3
XFILLER_32_158 VGND VGND VPWR VPWR sky130_fd_sc_hd__fill_1
XFILLER_60_489 VGND VGND VPWR VPWR sky130_fd_sc_hd__decap_3
XFILLER_9_343 VGND VGND VPWR VPWR sky130_fd_sc_hd__decap_3
XFILLER_70_6 VGND VGND VPWR VPWR sky130_fd_sc_hd__decap_3
XFILLER_114_436 VGND VGND VPWR VPWR sky130_fd_sc_hd__fill_2
X_5270_ _5270_/A0 _5040_/X _5274_/S VGND VGND VPWR VPWR _7195_/D sky130_fd_sc_hd__mux2_2
XFILLER_99_125 VGND VGND VPWR VPWR sky130_fd_sc_hd__fill_2
XFILLER_49_3 VGND VGND VPWR VPWR sky130_fd_sc_hd__decap_3
X_4221_ _7228_/Q _4469_/A3 _4510_/S _7041_/Q _4220_/X VGND VGND VPWR VPWR _4221_/X
+ sky130_fd_sc_hd__a221o_2
XTAP_TAPCELL_ROW_93_1369 VGND VPWR sky130_fd_sc_hd__tapvpwrvgnd_1
XFILLER_99_169 VGND VGND VPWR VPWR sky130_fd_sc_hd__fill_1
XFILLER_99_147 VGND VGND VPWR VPWR sky130_fd_sc_hd__fill_2
XFILLER_110_631 VGND VGND VPWR VPWR sky130_fd_sc_hd__decap_3
X_4152_ _7106_/Q _4250_/A2 _4195_/A2 _7138_/Q VGND VGND VPWR VPWR _4152_/X sky130_fd_sc_hd__a22o_2
XFILLER_110_675 VGND VGND VPWR VPWR sky130_fd_sc_hd__decap_3
XFILLER_68_589 VGND VGND VPWR VPWR sky130_fd_sc_hd__decap_3
X_4083_ _7366_/Q _4429_/B1 _4261_/B1 _7174_/Q VGND VGND VPWR VPWR _4083_/X sky130_fd_sc_hd__a22o_2
XFILLER_55_239 VGND VGND VPWR VPWR sky130_fd_sc_hd__decap_3
XFILLER_36_442 VGND VGND VPWR VPWR sky130_fd_sc_hd__decap_3
XFILLER_48_291 VGND VGND VPWR VPWR sky130_fd_sc_hd__decap_3
XFILLER_24_626 VGND VGND VPWR VPWR sky130_fd_sc_hd__fill_1
XFILLER_63_261 VGND VGND VPWR VPWR sky130_fd_sc_hd__decap_3
XFILLER_23_125 VGND VGND VPWR VPWR sky130_fd_sc_hd__fill_1
Xplace272 _3665_/X VGND VGND VPWR VPWR _3892_/B1 sky130_fd_sc_hd__buf_2
X_4985_ _4620_/A _5032_/A _5031_/B _4630_/X VGND VGND VPWR VPWR _5003_/B sky130_fd_sc_hd__a31o_2
XFILLER_23_169 VGND VGND VPWR VPWR sky130_fd_sc_hd__decap_3
Xplace294 _3913_/A2 VGND VGND VPWR VPWR _3883_/A2 sky130_fd_sc_hd__buf_2
Xplace283 _3925_/A2 VGND VGND VPWR VPWR _3767_/A2 sky130_fd_sc_hd__buf_2
X_6724_ _6971_/CLK _6724_/D VGND VGND VPWR VPWR _6724_/Q sky130_fd_sc_hd__dfxtp_2
XTAP_TAPCELL_ROW_34_665 VGND VPWR sky130_fd_sc_hd__tapvpwrvgnd_1
XTAP_TAPCELL_ROW_34_654 VGND VPWR sky130_fd_sc_hd__tapvpwrvgnd_1
XTAP_TAPCELL_ROW_62_996 VGND VPWR sky130_fd_sc_hd__tapvpwrvgnd_1
XTAP_TAPCELL_ROW_102_1476 VGND VPWR sky130_fd_sc_hd__tapvpwrvgnd_1
XFILLER_109_208 VGND VGND VPWR VPWR sky130_fd_sc_hd__decap_3
X_6655_ _6670_/A VGND VGND VPWR VPWR _6655_/Y sky130_fd_sc_hd__inv_2
X_3867_ _3629_/Y _3866_/X _3864_/S VGND VGND VPWR VPWR _3867_/X sky130_fd_sc_hd__o21a_2
X_6586_ _6587_/A VGND VGND VPWR VPWR _6586_/Y sky130_fd_sc_hd__inv_2
X_3798_ _6738_/Q _3651_/Y _3892_/B1 _6744_/Q _3797_/X VGND VGND VPWR VPWR _3798_/X
+ sky130_fd_sc_hd__a221o_2
XFILLER_11_36 VGND VGND VPWR VPWR sky130_fd_sc_hd__decap_3
XFILLER_105_414 VGND VGND VPWR VPWR sky130_fd_sc_hd__decap_3
XFILLER_11_69 VGND VGND VPWR VPWR sky130_fd_sc_hd__decap_3
XFILLER_105_458 VGND VGND VPWR VPWR sky130_fd_sc_hd__decap_3
XFILLER_78_309 VGND VGND VPWR VPWR sky130_fd_sc_hd__decap_3
XFILLER_87_18 VGND VGND VPWR VPWR sky130_fd_sc_hd__decap_3
X_7207_ _7337_/CLK _7207_/D _6487_/Y VGND VGND VPWR VPWR _7207_/Q sky130_fd_sc_hd__dfrtp_2
X_4419_ _7304_/Q _4493_/S _4419_/B1 _7368_/Q _4248_/A VGND VGND VPWR VPWR _4419_/X
+ sky130_fd_sc_hd__a221o_2
XTAP_TAPCELL_ROW_6_324 VGND VPWR sky130_fd_sc_hd__tapvpwrvgnd_1
XFILLER_101_620 VGND VGND VPWR VPWR sky130_fd_sc_hd__decap_3
XFILLER_86_320 VGND VGND VPWR VPWR sky130_fd_sc_hd__fill_2
X_7138_ _7266_/CLK _7138_/D _6418_/Y VGND VGND VPWR VPWR _7138_/Q sky130_fd_sc_hd__dfrtp_2
XFILLER_101_653 VGND VGND VPWR VPWR sky130_fd_sc_hd__decap_3
XFILLER_46_206 VGND VGND VPWR VPWR sky130_fd_sc_hd__decap_3
XFILLER_59_578 VGND VGND VPWR VPWR sky130_fd_sc_hd__decap_3
XFILLER_86_342 VGND VGND VPWR VPWR sky130_fd_sc_hd__fill_1
X_7069_ clkload7/A _7069_/D _6349_/Y VGND VGND VPWR VPWR _7069_/Q sky130_fd_sc_hd__dfrtp_2
XFILLER_100_174 VGND VGND VPWR VPWR sky130_fd_sc_hd__decap_3
XFILLER_46_239 VGND VGND VPWR VPWR sky130_fd_sc_hd__decap_3
XFILLER_74_559 VGND VGND VPWR VPWR sky130_fd_sc_hd__decap_3
XTAP_TAPCELL_ROW_68_1073 VGND VPWR sky130_fd_sc_hd__tapvpwrvgnd_1
XTAP_TAPCELL_ROW_68_1062 VGND VPWR sky130_fd_sc_hd__tapvpwrvgnd_1
XFILLER_15_637 VGND VGND VPWR VPWR sky130_fd_sc_hd__fill_1
XFILLER_82_592 VGND VGND VPWR VPWR sky130_fd_sc_hd__decap_3
XFILLER_14_158 VGND VGND VPWR VPWR sky130_fd_sc_hd__fill_2
XFILLER_30_629 VGND VGND VPWR VPWR sky130_fd_sc_hd__decap_3
XFILLER_52_65 VGND VGND VPWR VPWR sky130_fd_sc_hd__decap_3
XFILLER_6_368 VGND VGND VPWR VPWR sky130_fd_sc_hd__fill_1
XFILLER_96_106 VGND VGND VPWR VPWR sky130_fd_sc_hd__decap_3
XFILLER_97_629 VGND VGND VPWR VPWR sky130_fd_sc_hd__decap_3
XFILLER_104_480 VGND VGND VPWR VPWR sky130_fd_sc_hd__decap_3
XFILLER_111_439 VGND VGND VPWR VPWR sky130_fd_sc_hd__fill_1
XFILLER_77_73 VGND VGND VPWR VPWR sky130_fd_sc_hd__decap_3
XFILLER_96_139 VGND VGND VPWR VPWR sky130_fd_sc_hd__fill_1
XFILLER_77_95 VGND VGND VPWR VPWR sky130_fd_sc_hd__decap_3
XFILLER_37_228 VGND VGND VPWR VPWR sky130_fd_sc_hd__decap_3
XFILLER_37_239 VGND VGND VPWR VPWR sky130_fd_sc_hd__decap_3
XFILLER_18_442 VGND VGND VPWR VPWR sky130_fd_sc_hd__fill_1
XFILLER_80_507 VGND VGND VPWR VPWR sky130_fd_sc_hd__decap_3
XFILLER_18_475 VGND VGND VPWR VPWR sky130_fd_sc_hd__fill_1
XFILLER_45_272 VGND VGND VPWR VPWR sky130_fd_sc_hd__decap_3
XFILLER_73_581 VGND VGND VPWR VPWR sky130_fd_sc_hd__decap_3
XFILLER_92_389 VGND VGND VPWR VPWR sky130_fd_sc_hd__decap_3
XFILLER_60_253 VGND VGND VPWR VPWR sky130_fd_sc_hd__decap_3
XFILLER_20_117 VGND VGND VPWR VPWR sky130_fd_sc_hd__decap_3
X_4770_ _4832_/A _3692_/X _5663_/A _3509_/B VGND VGND VPWR VPWR _4770_/X sky130_fd_sc_hd__a211o_2
XTAP_TAPCELL_ROW_31_624 VGND VPWR sky130_fd_sc_hd__tapvpwrvgnd_1
X_3721_ _6863_/Q _3882_/A2 _3884_/B1 _6855_/Q _3720_/X VGND VGND VPWR VPWR _3721_/X
+ sky130_fd_sc_hd__a221o_2
X_6440_ _6532_/A VGND VGND VPWR VPWR _6440_/Y sky130_fd_sc_hd__inv_2
X_6371_ _6567_/A VGND VGND VPWR VPWR _6371_/Y sky130_fd_sc_hd__inv_2
X_3583_ _3583_/A _3583_/B _3583_/C VGND VGND VPWR VPWR _3583_/X sky130_fd_sc_hd__or3_4
XTAP_TAPCELL_ROW_11_381 VGND VPWR sky130_fd_sc_hd__tapvpwrvgnd_1
XFILLER_114_200 VGND VGND VPWR VPWR sky130_fd_sc_hd__decap_3
XFILLER_114_233 VGND VGND VPWR VPWR sky130_fd_sc_hd__decap_3
XFILLER_114_277 VGND VGND VPWR VPWR sky130_fd_sc_hd__decap_3
XFILLER_88_629 VGND VGND VPWR VPWR sky130_fd_sc_hd__decap_3
X_5253_ _5253_/A0 _4913_/X _5262_/S VGND VGND VPWR VPWR _7203_/D sky130_fd_sc_hd__mux2_2
XFILLER_102_439 VGND VGND VPWR VPWR sky130_fd_sc_hd__decap_3
XFILLER_87_128 VGND VGND VPWR VPWR sky130_fd_sc_hd__decap_3
X_5184_ _5184_/A _5205_/B VGND VGND VPWR VPWR _7236_/D sky130_fd_sc_hd__and2_2
X_4204_ _4936_/A _4201_/X _4203_/X VGND VGND VPWR VPWR _4204_/Y sky130_fd_sc_hd__o21bai_2
XFILLER_3_81 VGND VGND VPWR VPWR sky130_fd_sc_hd__decap_3
XFILLER_96_651 VGND VGND VPWR VPWR sky130_fd_sc_hd__decap_3
X_4135_ _7107_/Q _4250_/A2 _4195_/A2 _7139_/Q VGND VGND VPWR VPWR _4135_/X sky130_fd_sc_hd__a22o_2
XFILLER_113_27 VGND VGND VPWR VPWR sky130_fd_sc_hd__decap_3
XFILLER_28_206 VGND VGND VPWR VPWR sky130_fd_sc_hd__decap_3
XFILLER_28_228 VGND VGND VPWR VPWR sky130_fd_sc_hd__decap_3
XFILLER_83_323 VGND VGND VPWR VPWR sky130_fd_sc_hd__decap_3
XFILLER_95_172 VGND VGND VPWR VPWR sky130_fd_sc_hd__decap_3
XFILLER_96_684 VGND VGND VPWR VPWR sky130_fd_sc_hd__decap_3
XTAP_TAPCELL_ROW_39_724 VGND VPWR sky130_fd_sc_hd__tapvpwrvgnd_1
X_4066_ _4062_/X _4065_/X _4425_/A VGND VGND VPWR VPWR _4082_/A sky130_fd_sc_hd__o21a_2
XFILLER_36_261 VGND VGND VPWR VPWR sky130_fd_sc_hd__decap_3
XFILLER_83_389 VGND VGND VPWR VPWR sky130_fd_sc_hd__decap_3
XTAP_TAPCELL_ROW_104_1505 VGND VPWR sky130_fd_sc_hd__tapvpwrvgnd_1
XFILLER_24_434 VGND VGND VPWR VPWR sky130_fd_sc_hd__fill_1
XFILLER_64_592 VGND VGND VPWR VPWR sky130_fd_sc_hd__decap_3
XTAP_TAPCELL_ROW_19_481 VGND VPWR sky130_fd_sc_hd__tapvpwrvgnd_1
XFILLER_24_456 VGND VGND VPWR VPWR sky130_fd_sc_hd__fill_2
XFILLER_51_264 VGND VGND VPWR VPWR sky130_fd_sc_hd__decap_3
XFILLER_11_128 VGND VGND VPWR VPWR sky130_fd_sc_hd__decap_3
XFILLER_51_297 VGND VGND VPWR VPWR sky130_fd_sc_hd__decap_3
X_4968_ _4968_/A _4967_/B VGND VGND VPWR VPWR _4968_/Y sky130_fd_sc_hd__nor2b_2
XFILLER_20_640 VGND VGND VPWR VPWR sky130_fd_sc_hd__decap_3
XFILLER_22_24 VGND VGND VPWR VPWR sky130_fd_sc_hd__decap_3
X_6707_ _7405_/CLK _6707_/D VGND VGND VPWR VPWR _6707_/Q sky130_fd_sc_hd__dfxtp_2
X_4899_ _3341_/A _6998_/D _5656_/B _4898_/X VGND VGND VPWR VPWR _4899_/X sky130_fd_sc_hd__o22a_2
X_3919_ _5660_/A _3918_/X _4466_/A VGND VGND VPWR VPWR _3919_/X sky130_fd_sc_hd__a21o_2
X_6638_ _6638_/A VGND VGND VPWR VPWR _6638_/Y sky130_fd_sc_hd__inv_2
X_6569_ _6638_/A VGND VGND VPWR VPWR _6569_/Y sky130_fd_sc_hd__inv_2
XTAP_TAPCELL_ROW_115_1634 VGND VPWR sky130_fd_sc_hd__tapvpwrvgnd_1
XFILLER_105_255 VGND VGND VPWR VPWR sky130_fd_sc_hd__decap_3
XFILLER_79_629 VGND VGND VPWR VPWR sky130_fd_sc_hd__decap_3
Xoutput470 _4973_/B VGND VGND VPWR VPWR alu_result_out[16] sky130_fd_sc_hd__clkdlybuf4s25_1
XFILLER_78_139 VGND VGND VPWR VPWR sky130_fd_sc_hd__fill_1
Xoutput492 _5117_/B VGND VGND VPWR VPWR alu_result_out[7] sky130_fd_sc_hd__clkdlybuf4s25_1
Xoutput481 _5656_/A VGND VGND VPWR VPWR alu_result_out[26] sky130_fd_sc_hd__clkdlybuf4s25_1
XFILLER_47_21 VGND VGND VPWR VPWR sky130_fd_sc_hd__decap_3
XFILLER_87_662 VGND VGND VPWR VPWR sky130_fd_sc_hd__decap_3
XFILLER_87_673 VGND VGND VPWR VPWR sky130_fd_sc_hd__decap_3
XFILLER_19_206 VGND VGND VPWR VPWR sky130_fd_sc_hd__decap_3
XFILLER_47_43 VGND VGND VPWR VPWR sky130_fd_sc_hd__decap_3
XFILLER_59_375 VGND VGND VPWR VPWR sky130_fd_sc_hd__decap_3
XFILLER_59_386 VGND VGND VPWR VPWR sky130_fd_sc_hd__decap_3
XFILLER_86_172 VGND VGND VPWR VPWR sky130_fd_sc_hd__decap_3
XFILLER_19_239 VGND VGND VPWR VPWR sky130_fd_sc_hd__decap_3
XFILLER_47_98 VGND VGND VPWR VPWR sky130_fd_sc_hd__decap_3
XFILLER_74_345 VGND VGND VPWR VPWR sky130_fd_sc_hd__decap_3
XFILLER_86_194 VGND VGND VPWR VPWR sky130_fd_sc_hd__fill_2
XFILLER_34_209 VGND VGND VPWR VPWR sky130_fd_sc_hd__decap_3
XFILLER_62_518 VGND VGND VPWR VPWR sky130_fd_sc_hd__decap_3
XFILLER_63_31 VGND VGND VPWR VPWR sky130_fd_sc_hd__decap_3
XFILLER_42_253 VGND VGND VPWR VPWR sky130_fd_sc_hd__decap_3
XFILLER_63_53 VGND VGND VPWR VPWR sky130_fd_sc_hd__decap_3
XFILLER_63_64 VGND VGND VPWR VPWR sky130_fd_sc_hd__decap_3
XPHY_EDGE_ROW_69_Right_69 VGND VGND VPWR VPWR sky130_fd_sc_hd__decap_3
XFILLER_15_489 VGND VGND VPWR VPWR sky130_fd_sc_hd__fill_1
XFILLER_30_426 VGND VGND VPWR VPWR sky130_fd_sc_hd__decap_3
XFILLER_30_437 VGND VGND VPWR VPWR sky130_fd_sc_hd__fill_2
XFILLER_63_97 VGND VGND VPWR VPWR sky130_fd_sc_hd__decap_3
XFILLER_70_595 VGND VGND VPWR VPWR sky130_fd_sc_hd__decap_3
XFILLER_11_651 VGND VGND VPWR VPWR sky130_fd_sc_hd__fill_2
XFILLER_30_448 VGND VGND VPWR VPWR sky130_fd_sc_hd__fill_1
XFILLER_11_673 VGND VGND VPWR VPWR sky130_fd_sc_hd__decap_3
XFILLER_7_633 VGND VGND VPWR VPWR sky130_fd_sc_hd__fill_1
XFILLER_8_59 VGND VGND VPWR VPWR sky130_fd_sc_hd__decap_3
XFILLER_6_121 VGND VGND VPWR VPWR sky130_fd_sc_hd__decap_3
XFILLER_7_666 VGND VGND VPWR VPWR sky130_fd_sc_hd__decap_3
Xwire575 _6483_/A VGND VGND VPWR VPWR _6522_/A sky130_fd_sc_hd__buf_2
XFILLER_109_561 VGND VGND VPWR VPWR sky130_fd_sc_hd__decap_3
XFILLER_109_594 VGND VGND VPWR VPWR sky130_fd_sc_hd__decap_3
XFILLER_7_688 VGND VGND VPWR VPWR sky130_fd_sc_hd__decap_3
XPHY_EDGE_ROW_78_Right_78 VGND VGND VPWR VPWR sky130_fd_sc_hd__decap_3
XTAP_TAPCELL_ROW_90_1328 VGND VPWR sky130_fd_sc_hd__tapvpwrvgnd_1
XFILLER_111_214 VGND VGND VPWR VPWR sky130_fd_sc_hd__decap_3
XFILLER_111_225 VGND VGND VPWR VPWR sky130_fd_sc_hd__fill_2
XFILLER_2_371 VGND VGND VPWR VPWR sky130_fd_sc_hd__decap_3
XFILLER_33_6 VGND VGND VPWR VPWR sky130_fd_sc_hd__decap_3
XFILLER_97_437 VGND VGND VPWR VPWR sky130_fd_sc_hd__fill_2
XFILLER_111_269 VGND VGND VPWR VPWR sky130_fd_sc_hd__decap_3
XFILLER_78_640 VGND VGND VPWR VPWR sky130_fd_sc_hd__decap_3
XFILLER_78_651 VGND VGND VPWR VPWR sky130_fd_sc_hd__decap_3
XFILLER_93_632 VGND VGND VPWR VPWR sky130_fd_sc_hd__decap_3
XFILLER_65_334 VGND VGND VPWR VPWR sky130_fd_sc_hd__fill_2
XFILLER_93_665 VGND VGND VPWR VPWR sky130_fd_sc_hd__decap_3
XFILLER_46_570 VGND VGND VPWR VPWR sky130_fd_sc_hd__decap_3
XFILLER_65_378 VGND VGND VPWR VPWR sky130_fd_sc_hd__decap_3
XFILLER_80_304 VGND VGND VPWR VPWR sky130_fd_sc_hd__decap_3
XFILLER_93_676 VGND VGND VPWR VPWR sky130_fd_sc_hd__decap_3
XFILLER_33_220 VGND VGND VPWR VPWR sky130_fd_sc_hd__decap_3
XFILLER_46_592 VGND VGND VPWR VPWR sky130_fd_sc_hd__decap_3
XFILLER_92_197 VGND VGND VPWR VPWR sky130_fd_sc_hd__decap_3
XPHY_EDGE_ROW_87_Right_87 VGND VGND VPWR VPWR sky130_fd_sc_hd__decap_3
XFILLER_33_231 VGND VGND VPWR VPWR sky130_fd_sc_hd__decap_3
XTAP_TAPCELL_ROW_16_440 VGND VPWR sky130_fd_sc_hd__tapvpwrvgnd_1
XFILLER_33_297 VGND VGND VPWR VPWR sky130_fd_sc_hd__decap_3
XFILLER_61_584 VGND VGND VPWR VPWR sky130_fd_sc_hd__decap_3
X_4822_ _4836_/S _7002_/D _5663_/B _4821_/X VGND VGND VPWR VPWR _4822_/X sky130_fd_sc_hd__o22a_2
XTAP_TAPCELL_ROW_44_782 VGND VPWR sky130_fd_sc_hd__tapvpwrvgnd_1
X_4753_ _4753_/A0 _4752_/X _4837_/S VGND VGND VPWR VPWR _7276_/D sky130_fd_sc_hd__mux2_2
X_3704_ _6712_/Q _3767_/A2 _3767_/B1 _6890_/Q _3703_/X VGND VGND VPWR VPWR _3704_/X
+ sky130_fd_sc_hd__a221o_2
X_6423_ _6617_/A VGND VGND VPWR VPWR _6423_/Y sky130_fd_sc_hd__inv_2
X_4684_ _6996_/Q _4668_/X _4943_/A _4683_/X VGND VGND VPWR VPWR _4684_/X sky130_fd_sc_hd__a31o_2
X_3635_ _3635_/A _3635_/B _3547_/A VGND VGND VPWR VPWR _3635_/X sky130_fd_sc_hd__or3b_2
XPHY_EDGE_ROW_96_Right_96 VGND VGND VPWR VPWR sky130_fd_sc_hd__decap_3
XFILLER_108_27 VGND VGND VPWR VPWR sky130_fd_sc_hd__fill_1
XFILLER_108_38 VGND VGND VPWR VPWR sky130_fd_sc_hd__decap_3
XFILLER_115_520 VGND VGND VPWR VPWR sky130_fd_sc_hd__decap_3
X_6354_ _6388_/A VGND VGND VPWR VPWR _6354_/Y sky130_fd_sc_hd__inv_2
X_3566_ _7189_/Q _3989_/S _4332_/B1 _7381_/Q VGND VGND VPWR VPWR _3566_/X sky130_fd_sc_hd__a22o_2
XFILLER_115_553 VGND VGND VPWR VPWR sky130_fd_sc_hd__decap_3
XFILLER_115_564 VGND VGND VPWR VPWR sky130_fd_sc_hd__decap_3
XFILLER_88_404 VGND VGND VPWR VPWR sky130_fd_sc_hd__decap_3
X_6285_ _6285_/A VGND VGND VPWR VPWR _6285_/Y sky130_fd_sc_hd__inv_2
X_3497_ _7151_/Q _3409_/X _3493_/X _3496_/X VGND VGND VPWR VPWR _3497_/X sky130_fd_sc_hd__a211o_2
XFILLER_115_597 VGND VGND VPWR VPWR sky130_fd_sc_hd__decap_3
XFILLER_88_448 VGND VGND VPWR VPWR sky130_fd_sc_hd__decap_3
X_5236_ _5236_/A0 _4752_/X _5245_/S VGND VGND VPWR VPWR _7212_/D sky130_fd_sc_hd__mux2_2
XFILLER_69_662 VGND VGND VPWR VPWR sky130_fd_sc_hd__decap_3
XTAP_TAPCELL_ROW_110_1575 VGND VPWR sky130_fd_sc_hd__tapvpwrvgnd_1
XFILLER_56_312 VGND VGND VPWR VPWR sky130_fd_sc_hd__decap_3
XFILLER_68_161 VGND VGND VPWR VPWR sky130_fd_sc_hd__decap_3
XFILLER_69_673 VGND VGND VPWR VPWR sky130_fd_sc_hd__decap_3
XFILLER_84_610 VGND VGND VPWR VPWR sky130_fd_sc_hd__decap_3
XFILLER_96_470 VGND VGND VPWR VPWR sky130_fd_sc_hd__decap_3
X_5167_ _5167_/A _5182_/B VGND VGND VPWR VPWR _7244_/D sky130_fd_sc_hd__and2_2
XPHY_EDGE_ROW_3_Left_120 VGND VGND VPWR VPWR sky130_fd_sc_hd__decap_3
XFILLER_110_280 VGND VGND VPWR VPWR sky130_fd_sc_hd__decap_3
XFILLER_29_559 VGND VGND VPWR VPWR sky130_fd_sc_hd__fill_1
XFILLER_83_131 VGND VGND VPWR VPWR sky130_fd_sc_hd__decap_3
XFILLER_84_643 VGND VGND VPWR VPWR sky130_fd_sc_hd__fill_1
XFILLER_84_654 VGND VGND VPWR VPWR sky130_fd_sc_hd__decap_3
X_5098_ _5098_/A _5098_/B VGND VGND VPWR VPWR _6985_/D sky130_fd_sc_hd__nor2_2
X_4118_ _7021_/Q _4356_/A2 _4394_/B _7364_/Q VGND VGND VPWR VPWR _4118_/X sky130_fd_sc_hd__a22o_2
XFILLER_16_209 VGND VGND VPWR VPWR sky130_fd_sc_hd__decap_3
XFILLER_17_24 VGND VGND VPWR VPWR sky130_fd_sc_hd__decap_3
XFILLER_56_389 VGND VGND VPWR VPWR sky130_fd_sc_hd__decap_3
XFILLER_71_304 VGND VGND VPWR VPWR sky130_fd_sc_hd__decap_3
XFILLER_84_687 VGND VGND VPWR VPWR sky130_fd_sc_hd__decap_3
X_4049_ _7213_/Q _3935_/S _4837_/S _7309_/Q _4048_/X VGND VGND VPWR VPWR _4049_/X
+ sky130_fd_sc_hd__a221o_2
XFILLER_17_57 VGND VGND VPWR VPWR sky130_fd_sc_hd__decap_3
XFILLER_71_337 VGND VGND VPWR VPWR sky130_fd_sc_hd__decap_3
XFILLER_24_242 VGND VGND VPWR VPWR sky130_fd_sc_hd__decap_3
XFILLER_24_253 VGND VGND VPWR VPWR sky130_fd_sc_hd__decap_3
XFILLER_52_540 VGND VGND VPWR VPWR sky130_fd_sc_hd__decap_3
XFILLER_71_359 VGND VGND VPWR VPWR sky130_fd_sc_hd__decap_3
XTAP_TAPCELL_ROW_65_1032 VGND VPWR sky130_fd_sc_hd__tapvpwrvgnd_1
XFILLER_24_286 VGND VGND VPWR VPWR sky130_fd_sc_hd__decap_3
XFILLER_33_12 VGND VGND VPWR VPWR sky130_fd_sc_hd__decap_3
XFILLER_52_595 VGND VGND VPWR VPWR sky130_fd_sc_hd__decap_3
XFILLER_33_78 VGND VGND VPWR VPWR sky130_fd_sc_hd__decap_3
XPHY_EDGE_ROW_49_Left_166 VGND VGND VPWR VPWR sky130_fd_sc_hd__decap_3
XFILLER_3_102 VGND VGND VPWR VPWR sky130_fd_sc_hd__decap_3
XFILLER_106_542 VGND VGND VPWR VPWR sky130_fd_sc_hd__decap_3
XFILLER_3_113 VGND VGND VPWR VPWR sky130_fd_sc_hd__decap_3
XFILLER_106_564 VGND VGND VPWR VPWR sky130_fd_sc_hd__decap_3
XFILLER_3_146 VGND VGND VPWR VPWR sky130_fd_sc_hd__decap_3
XFILLER_4_669 VGND VGND VPWR VPWR sky130_fd_sc_hd__decap_3
XTAP_TAPCELL_ROW_76_1161 VGND VPWR sky130_fd_sc_hd__tapvpwrvgnd_1
XFILLER_58_75 VGND VGND VPWR VPWR sky130_fd_sc_hd__decap_3
XFILLER_59_172 VGND VGND VPWR VPWR sky130_fd_sc_hd__decap_3
XFILLER_87_470 VGND VGND VPWR VPWR sky130_fd_sc_hd__decap_3
XPHY_EDGE_ROW_58_Left_175 VGND VGND VPWR VPWR sky130_fd_sc_hd__decap_3
XFILLER_47_323 VGND VGND VPWR VPWR sky130_fd_sc_hd__decap_3
XFILLER_47_345 VGND VGND VPWR VPWR sky130_fd_sc_hd__fill_1
XFILLER_75_654 VGND VGND VPWR VPWR sky130_fd_sc_hd__decap_3
XFILLER_47_389 VGND VGND VPWR VPWR sky130_fd_sc_hd__decap_3
XFILLER_74_41 VGND VGND VPWR VPWR sky130_fd_sc_hd__fill_2
XFILLER_75_676 VGND VGND VPWR VPWR sky130_fd_sc_hd__decap_3
XFILLER_74_197 VGND VGND VPWR VPWR sky130_fd_sc_hd__decap_3
XFILLER_74_85 VGND VGND VPWR VPWR sky130_fd_sc_hd__decap_3
XFILLER_90_657 VGND VGND VPWR VPWR sky130_fd_sc_hd__decap_3
XFILLER_15_231 VGND VGND VPWR VPWR sky130_fd_sc_hd__decap_3
XTAP_TAPCELL_ROW_87_1290 VGND VPWR sky130_fd_sc_hd__tapvpwrvgnd_1
XFILLER_30_245 VGND VGND VPWR VPWR sky130_fd_sc_hd__decap_3
XFILLER_90_40 VGND VGND VPWR VPWR sky130_fd_sc_hd__decap_3
XFILLER_90_73 VGND VGND VPWR VPWR sky130_fd_sc_hd__decap_3
XTAP_TAPCELL_ROW_41_741 VGND VPWR sky130_fd_sc_hd__tapvpwrvgnd_1
XTAP_TAPCELL_ROW_13_410 VGND VPWR sky130_fd_sc_hd__tapvpwrvgnd_1
XPHY_EDGE_ROW_67_Left_184 VGND VGND VPWR VPWR sky130_fd_sc_hd__decap_3
XFILLER_30_256 VGND VGND VPWR VPWR sky130_fd_sc_hd__decap_3
XFILLER_7_452 VGND VGND VPWR VPWR sky130_fd_sc_hd__decap_3
X_3420_ _3420_/A _5642_/B VGND VGND VPWR VPWR _3442_/B sky130_fd_sc_hd__or2_2
XFILLER_99_60 VGND VGND VPWR VPWR sky130_fd_sc_hd__decap_3
XFILLER_112_501 VGND VGND VPWR VPWR sky130_fd_sc_hd__decap_3
X_3351_ _5130_/A _3350_/Y _3340_/B VGND VGND VPWR VPWR _5642_/B sky130_fd_sc_hd__o21a_2
XFILLER_99_93 VGND VGND VPWR VPWR sky130_fd_sc_hd__decap_3
XFILLER_112_512 VGND VGND VPWR VPWR sky130_fd_sc_hd__decap_3
XFILLER_31_3 VGND VGND VPWR VPWR sky130_fd_sc_hd__decap_3
XFILLER_112_545 VGND VGND VPWR VPWR sky130_fd_sc_hd__decap_3
XFILLER_112_578 VGND VGND VPWR VPWR sky130_fd_sc_hd__decap_3
XFILLER_85_407 VGND VGND VPWR VPWR sky130_fd_sc_hd__decap_3
XPHY_EDGE_ROW_76_Left_193 VGND VGND VPWR VPWR sky130_fd_sc_hd__decap_3
XFILLER_112_589 VGND VGND VPWR VPWR sky130_fd_sc_hd__decap_3
XFILLER_57_109 VGND VGND VPWR VPWR sky130_fd_sc_hd__decap_3
XFILLER_66_610 VGND VGND VPWR VPWR sky130_fd_sc_hd__decap_3
Xhold1108 _7268_/Q VGND VGND VPWR VPWR _4901_/A0 sky130_fd_sc_hd__dlygate4sd3_1
Xhold1119 _7152_/Q VGND VGND VPWR VPWR _5358_/A0 sky130_fd_sc_hd__dlygate4sd3_1
X_5021_ _5072_/A _4372_/A _5018_/A _5101_/A VGND VGND VPWR VPWR _5021_/X sky130_fd_sc_hd__o2bb2a_2
XFILLER_38_323 VGND VGND VPWR VPWR sky130_fd_sc_hd__fill_2
XFILLER_65_131 VGND VGND VPWR VPWR sky130_fd_sc_hd__decap_3
XFILLER_66_643 VGND VGND VPWR VPWR sky130_fd_sc_hd__fill_1
XFILLER_66_654 VGND VGND VPWR VPWR sky130_fd_sc_hd__decap_3
Xsingle_cycle_cpu_582 VGND VGND VPWR VPWR instruction_out[1] single_cycle_cpu_582/LO
+ sky130_fd_sc_hd__conb_1
XTAP_TAPCELL_ROW_49_841 VGND VPWR sky130_fd_sc_hd__tapvpwrvgnd_1
XFILLER_53_304 VGND VGND VPWR VPWR sky130_fd_sc_hd__decap_3
XFILLER_65_153 VGND VGND VPWR VPWR sky130_fd_sc_hd__decap_3
XFILLER_66_687 VGND VGND VPWR VPWR sky130_fd_sc_hd__decap_3
XFILLER_81_613 VGND VGND VPWR VPWR sky130_fd_sc_hd__decap_3
XFILLER_0_71 VGND VGND VPWR VPWR sky130_fd_sc_hd__decap_3
XFILLER_19_581 VGND VGND VPWR VPWR sky130_fd_sc_hd__decap_3
XFILLER_65_175 VGND VGND VPWR VPWR sky130_fd_sc_hd__decap_3
XFILLER_80_123 VGND VGND VPWR VPWR sky130_fd_sc_hd__decap_3
XFILLER_81_635 VGND VGND VPWR VPWR sky130_fd_sc_hd__decap_3
X_6972_ _6972_/CLK _6972_/D VGND VGND VPWR VPWR _6972_/Q sky130_fd_sc_hd__dfxtp_2
XFILLER_81_668 VGND VGND VPWR VPWR sky130_fd_sc_hd__decap_3
XFILLER_81_679 VGND VGND VPWR VPWR sky130_fd_sc_hd__decap_3
XFILLER_61_370 VGND VGND VPWR VPWR sky130_fd_sc_hd__decap_3
XFILLER_80_178 VGND VGND VPWR VPWR sky130_fd_sc_hd__decap_3
XFILLER_21_223 VGND VGND VPWR VPWR sky130_fd_sc_hd__fill_1
XFILLER_21_234 VGND VGND VPWR VPWR sky130_fd_sc_hd__decap_3
X_4805_ _4997_/A1 _7003_/D _4804_/X VGND VGND VPWR VPWR _4805_/X sky130_fd_sc_hd__a21bo_2
XFILLER_21_278 VGND VGND VPWR VPWR sky130_fd_sc_hd__fill_2
XFILLER_107_317 VGND VGND VPWR VPWR sky130_fd_sc_hd__decap_3
X_4667_ _6998_/Q _4667_/B VGND VGND VPWR VPWR _4896_/A sky130_fd_sc_hd__xnor2_2
XFILLER_102_9 VGND VGND VPWR VPWR sky130_fd_sc_hd__decap_3
X_7386_ _7386_/CLK _7386_/D _6666_/Y VGND VGND VPWR VPWR _7386_/Q sky130_fd_sc_hd__dfrtp_2
Xhold920 _6696_/Q VGND VGND VPWR VPWR hold920/X sky130_fd_sc_hd__dlygate4sd3_1
Xhold931 _7014_/Q VGND VGND VPWR VPWR _5628_/A sky130_fd_sc_hd__dlygate4sd3_1
X_6406_ _6532_/A VGND VGND VPWR VPWR _6406_/Y sky130_fd_sc_hd__inv_2
X_3618_ _5118_/C _4938_/A _3618_/C VGND VGND VPWR VPWR _3618_/X sky130_fd_sc_hd__and3_2
XFILLER_103_501 VGND VGND VPWR VPWR sky130_fd_sc_hd__decap_3
XFILLER_115_361 VGND VGND VPWR VPWR sky130_fd_sc_hd__decap_3
XFILLER_1_606 VGND VGND VPWR VPWR sky130_fd_sc_hd__decap_3
Xhold964 _7046_/Q VGND VGND VPWR VPWR hold964/X sky130_fd_sc_hd__dlygate4sd3_1
Xhold953 _6710_/Q VGND VGND VPWR VPWR hold953/X sky130_fd_sc_hd__dlygate4sd3_1
Xhold942 _6713_/Q VGND VGND VPWR VPWR hold942/X sky130_fd_sc_hd__dlygate4sd3_1
X_6337_ _6347_/A VGND VGND VPWR VPWR _6337_/Y sky130_fd_sc_hd__inv_2
XFILLER_0_116 VGND VGND VPWR VPWR sky130_fd_sc_hd__fill_2
XFILLER_1_628 VGND VGND VPWR VPWR sky130_fd_sc_hd__decap_3
Xhold997 _7395_/Q VGND VGND VPWR VPWR hold997/X sky130_fd_sc_hd__dlygate4sd3_1
Xhold986 _7048_/Q VGND VGND VPWR VPWR hold986/X sky130_fd_sc_hd__dlygate4sd3_1
Xhold975 _7034_/Q VGND VGND VPWR VPWR _5587_/A sky130_fd_sc_hd__dlygate4sd3_1
XFILLER_0_138 VGND VGND VPWR VPWR sky130_fd_sc_hd__fill_2
X_6268_ _6366_/A VGND VGND VPWR VPWR _6268_/Y sky130_fd_sc_hd__inv_2
XFILLER_28_12 VGND VGND VPWR VPWR sky130_fd_sc_hd__decap_3
XFILLER_69_481 VGND VGND VPWR VPWR sky130_fd_sc_hd__fill_1
X_5219_ _5219_/A _5221_/B VGND VGND VPWR VPWR _7219_/D sky130_fd_sc_hd__and2_2
XFILLER_28_34 VGND VGND VPWR VPWR sky130_fd_sc_hd__decap_3
XFILLER_56_131 VGND VGND VPWR VPWR sky130_fd_sc_hd__decap_3
XFILLER_57_632 VGND VGND VPWR VPWR sky130_fd_sc_hd__decap_3
XFILLER_29_378 VGND VGND VPWR VPWR sky130_fd_sc_hd__decap_3
XFILLER_44_304 VGND VGND VPWR VPWR sky130_fd_sc_hd__decap_3
XFILLER_57_665 VGND VGND VPWR VPWR sky130_fd_sc_hd__decap_3
XFILLER_57_676 VGND VGND VPWR VPWR sky130_fd_sc_hd__decap_3
XFILLER_84_451 VGND VGND VPWR VPWR sky130_fd_sc_hd__decap_3
XFILLER_84_473 VGND VGND VPWR VPWR sky130_fd_sc_hd__decap_3
XFILLER_44_326 VGND VGND VPWR VPWR sky130_fd_sc_hd__decap_3
XFILLER_72_657 VGND VGND VPWR VPWR sky130_fd_sc_hd__decap_3
XFILLER_44_359 VGND VGND VPWR VPWR sky130_fd_sc_hd__decap_3
XFILLER_71_156 VGND VGND VPWR VPWR sky130_fd_sc_hd__decap_3
XFILLER_12_212 VGND VGND VPWR VPWR sky130_fd_sc_hd__fill_1
XFILLER_44_55 VGND VGND VPWR VPWR sky130_fd_sc_hd__decap_3
XTAP_TAPCELL_ROW_27_579 VGND VPWR sky130_fd_sc_hd__tapvpwrvgnd_1
XFILLER_12_245 VGND VGND VPWR VPWR sky130_fd_sc_hd__decap_3
XFILLER_80_690 VGND VGND VPWR VPWR sky130_fd_sc_hd__fill_2
XFILLER_100_72 VGND VGND VPWR VPWR sky130_fd_sc_hd__decap_3
XFILLER_60_21 VGND VGND VPWR VPWR sky130_fd_sc_hd__decap_3
XFILLER_100_94 VGND VGND VPWR VPWR sky130_fd_sc_hd__fill_2
XFILLER_12_289 VGND VGND VPWR VPWR sky130_fd_sc_hd__decap_3
XFILLER_60_65 VGND VGND VPWR VPWR sky130_fd_sc_hd__decap_3
XFILLER_8_249 VGND VGND VPWR VPWR sky130_fd_sc_hd__decap_3
XFILLER_4_400 VGND VGND VPWR VPWR sky130_fd_sc_hd__decap_3
XFILLER_4_433 VGND VGND VPWR VPWR sky130_fd_sc_hd__decap_3
XFILLER_5_27 VGND VGND VPWR VPWR sky130_fd_sc_hd__decap_3
XFILLER_109_81 VGND VGND VPWR VPWR sky130_fd_sc_hd__decap_3
XFILLER_4_477 VGND VGND VPWR VPWR sky130_fd_sc_hd__decap_3
XFILLER_69_41 VGND VGND VPWR VPWR sky130_fd_sc_hd__decap_3
XFILLER_106_383 VGND VGND VPWR VPWR sky130_fd_sc_hd__decap_3
XFILLER_69_63 VGND VGND VPWR VPWR sky130_fd_sc_hd__decap_3
XFILLER_69_96 VGND VGND VPWR VPWR sky130_fd_sc_hd__decap_3
XFILLER_79_234 VGND VGND VPWR VPWR sky130_fd_sc_hd__decap_3
XFILLER_48_610 VGND VGND VPWR VPWR sky130_fd_sc_hd__decap_3
XFILLER_94_226 VGND VGND VPWR VPWR sky130_fd_sc_hd__decap_3
XFILLER_47_131 VGND VGND VPWR VPWR sky130_fd_sc_hd__decap_3
XFILLER_48_643 VGND VGND VPWR VPWR sky130_fd_sc_hd__fill_1
XFILLER_48_654 VGND VGND VPWR VPWR sky130_fd_sc_hd__decap_3
XFILLER_85_51 VGND VGND VPWR VPWR sky130_fd_sc_hd__decap_3
XFILLER_35_304 VGND VGND VPWR VPWR sky130_fd_sc_hd__decap_3
XFILLER_63_613 VGND VGND VPWR VPWR sky130_fd_sc_hd__decap_3
XFILLER_85_73 VGND VGND VPWR VPWR sky130_fd_sc_hd__decap_3
XTAP_TAPCELL_ROW_46_800 VGND VPWR sky130_fd_sc_hd__tapvpwrvgnd_1
XFILLER_35_315 VGND VGND VPWR VPWR sky130_fd_sc_hd__decap_3
XFILLER_62_101 VGND VGND VPWR VPWR sky130_fd_sc_hd__decap_3
XFILLER_63_635 VGND VGND VPWR VPWR sky130_fd_sc_hd__decap_3
XFILLER_90_410 VGND VGND VPWR VPWR sky130_fd_sc_hd__decap_3
XFILLER_90_421 VGND VGND VPWR VPWR sky130_fd_sc_hd__decap_3
XFILLER_62_156 VGND VGND VPWR VPWR sky130_fd_sc_hd__decap_3
XFILLER_63_668 VGND VGND VPWR VPWR sky130_fd_sc_hd__decap_3
XFILLER_63_679 VGND VGND VPWR VPWR sky130_fd_sc_hd__decap_3
XFILLER_16_584 VGND VGND VPWR VPWR sky130_fd_sc_hd__decap_3
XFILLER_50_329 VGND VGND VPWR VPWR sky130_fd_sc_hd__decap_3
XFILLER_62_178 VGND VGND VPWR VPWR sky130_fd_sc_hd__decap_3
XFILLER_62_189 VGND VGND VPWR VPWR sky130_fd_sc_hd__decap_3
XFILLER_16_595 VGND VGND VPWR VPWR sky130_fd_sc_hd__decap_3
XFILLER_43_381 VGND VGND VPWR VPWR sky130_fd_sc_hd__fill_2
X_5570_ hold999/X _5570_/A2 _4929_/Y VGND VGND VPWR VPWR _7047_/D sky130_fd_sc_hd__o21a_2
XFILLER_116_103 VGND VGND VPWR VPWR sky130_fd_sc_hd__decap_3
XFILLER_7_271 VGND VGND VPWR VPWR sky130_fd_sc_hd__decap_3
X_7240_ _7368_/CLK _7240_/D _6520_/Y VGND VGND VPWR VPWR _7240_/Q sky130_fd_sc_hd__dfrtp_2
X_4452_ _4452_/A _4765_/B VGND VGND VPWR VPWR _4453_/A sky130_fd_sc_hd__or2_2
XFILLER_104_309 VGND VGND VPWR VPWR sky130_fd_sc_hd__decap_3
XFILLER_116_147 VGND VGND VPWR VPWR sky130_fd_sc_hd__decap_3
XFILLER_116_158 VGND VGND VPWR VPWR sky130_fd_sc_hd__decap_3
XFILLER_116_169 VGND VGND VPWR VPWR sky130_fd_sc_hd__decap_3
X_3403_ _3403_/A _4467_/B VGND VGND VPWR VPWR _4667_/B sky130_fd_sc_hd__or2_4
XPHY_EDGE_ROW_84_Left_201 VGND VGND VPWR VPWR sky130_fd_sc_hd__decap_3
X_7171_ _7363_/CLK _7171_/D _6451_/Y VGND VGND VPWR VPWR _7171_/Q sky130_fd_sc_hd__dfrtp_2
X_4383_ _4920_/A _4937_/A _4383_/C VGND VGND VPWR VPWR _4384_/C sky130_fd_sc_hd__and3_2
X_3334_ _3330_/Y _3528_/A _3341_/A VGND VGND VPWR VPWR _3334_/Y sky130_fd_sc_hd__o21ai_2
XFILLER_105_39 VGND VGND VPWR VPWR sky130_fd_sc_hd__decap_3
XFILLER_100_548 VGND VGND VPWR VPWR sky130_fd_sc_hd__fill_1
XFILLER_38_120 VGND VGND VPWR VPWR sky130_fd_sc_hd__decap_3
XFILLER_39_643 VGND VGND VPWR VPWR sky130_fd_sc_hd__decap_3
X_5004_ _5004_/A _5004_/B VGND VGND VPWR VPWR _5004_/X sky130_fd_sc_hd__or2_2
XFILLER_39_665 VGND VGND VPWR VPWR sky130_fd_sc_hd__decap_3
XFILLER_39_676 VGND VGND VPWR VPWR sky130_fd_sc_hd__decap_3
XFILLER_54_613 VGND VGND VPWR VPWR sky130_fd_sc_hd__decap_3
XFILLER_66_440 VGND VGND VPWR VPWR sky130_fd_sc_hd__decap_3
XFILLER_66_473 VGND VGND VPWR VPWR sky130_fd_sc_hd__decap_3
XFILLER_26_315 VGND VGND VPWR VPWR sky130_fd_sc_hd__decap_3
XFILLER_26_337 VGND VGND VPWR VPWR sky130_fd_sc_hd__decap_3
XFILLER_38_197 VGND VGND VPWR VPWR sky130_fd_sc_hd__fill_2
XFILLER_66_484 VGND VGND VPWR VPWR sky130_fd_sc_hd__decap_3
XFILLER_81_410 VGND VGND VPWR VPWR sky130_fd_sc_hd__decap_3
XFILLER_54_657 VGND VGND VPWR VPWR sky130_fd_sc_hd__fill_2
X_6955_ _6970_/CLK _6955_/D VGND VGND VPWR VPWR _6955_/Q sky130_fd_sc_hd__dfxtp_2
XPHY_EDGE_ROW_93_Left_210 VGND VGND VPWR VPWR sky130_fd_sc_hd__decap_3
XFILLER_41_307 VGND VGND VPWR VPWR sky130_fd_sc_hd__decap_3
XFILLER_41_318 VGND VGND VPWR VPWR sky130_fd_sc_hd__decap_3
XFILLER_53_178 VGND VGND VPWR VPWR sky130_fd_sc_hd__decap_3
XFILLER_81_498 VGND VGND VPWR VPWR sky130_fd_sc_hd__decap_3
XFILLER_62_690 VGND VGND VPWR VPWR sky130_fd_sc_hd__fill_2
X_6886_ _7406_/CLK _6886_/D VGND VGND VPWR VPWR _6886_/Q sky130_fd_sc_hd__dfxtp_2
XTAP_TAPCELL_ROW_24_538 VGND VPWR sky130_fd_sc_hd__tapvpwrvgnd_1
XFILLER_14_47 VGND VGND VPWR VPWR sky130_fd_sc_hd__decap_3
XFILLER_108_604 VGND VGND VPWR VPWR sky130_fd_sc_hd__decap_3
XFILLER_108_637 VGND VGND VPWR VPWR sky130_fd_sc_hd__decap_3
XFILLER_108_648 VGND VGND VPWR VPWR sky130_fd_sc_hd__decap_3
XFILLER_30_35 VGND VGND VPWR VPWR sky130_fd_sc_hd__decap_3
X_5699_ _7355_/Q hold944/X _5708_/S VGND VGND VPWR VPWR _6699_/D sky130_fd_sc_hd__mux2_2
XFILLER_100_6 VGND VGND VPWR VPWR sky130_fd_sc_hd__decap_3
XFILLER_30_68 VGND VGND VPWR VPWR sky130_fd_sc_hd__decap_3
XFILLER_116_670 VGND VGND VPWR VPWR sky130_fd_sc_hd__fill_2
XFILLER_1_414 VGND VGND VPWR VPWR sky130_fd_sc_hd__decap_3
X_7369_ _7372_/CLK _7369_/D _6649_/Y VGND VGND VPWR VPWR _7369_/Q sky130_fd_sc_hd__dfrtp_2
Xhold750 _6957_/Q VGND VGND VPWR VPWR _6957_/D sky130_fd_sc_hd__dlygate4sd3_1
Xhold761 _6732_/Q VGND VGND VPWR VPWR _6732_/D sky130_fd_sc_hd__dlygate4sd3_1
Xhold772 _6937_/Q VGND VGND VPWR VPWR _6937_/D sky130_fd_sc_hd__dlygate4sd3_1
XTAP_TAPCELL_ROW_73_1131 VGND VPWR sky130_fd_sc_hd__tapvpwrvgnd_1
XFILLER_1_447 VGND VGND VPWR VPWR sky130_fd_sc_hd__fill_1
XFILLER_1_458 VGND VGND VPWR VPWR sky130_fd_sc_hd__decap_3
Xhold783 _6781_/Q VGND VGND VPWR VPWR _6781_/D sky130_fd_sc_hd__dlygate4sd3_1
Xhold794 _6821_/Q VGND VGND VPWR VPWR _6821_/D sky130_fd_sc_hd__dlygate4sd3_1
XFILLER_49_407 VGND VGND VPWR VPWR sky130_fd_sc_hd__decap_3
XFILLER_89_576 VGND VGND VPWR VPWR sky130_fd_sc_hd__fill_1
XFILLER_89_598 VGND VGND VPWR VPWR sky130_fd_sc_hd__decap_3
XFILLER_76_248 VGND VGND VPWR VPWR sky130_fd_sc_hd__decap_3
XFILLER_29_131 VGND VGND VPWR VPWR sky130_fd_sc_hd__decap_3
XFILLER_29_142 VGND VGND VPWR VPWR sky130_fd_sc_hd__fill_1
XFILLER_17_337 VGND VGND VPWR VPWR sky130_fd_sc_hd__fill_2
XFILLER_44_101 VGND VGND VPWR VPWR sky130_fd_sc_hd__fill_2
XFILLER_44_112 VGND VGND VPWR VPWR sky130_fd_sc_hd__decap_3
XFILLER_55_21 VGND VGND VPWR VPWR sky130_fd_sc_hd__decap_3
XFILLER_72_421 VGND VGND VPWR VPWR sky130_fd_sc_hd__decap_3
XTAP_TAPCELL_ROW_4_296 VGND VPWR sky130_fd_sc_hd__tapvpwrvgnd_1
XFILLER_45_679 VGND VGND VPWR VPWR sky130_fd_sc_hd__decap_3
XFILLER_55_87 VGND VGND VPWR VPWR sky130_fd_sc_hd__fill_1
XFILLER_32_307 VGND VGND VPWR VPWR sky130_fd_sc_hd__fill_1
XFILLER_32_318 VGND VGND VPWR VPWR sky130_fd_sc_hd__decap_3
XFILLER_60_616 VGND VGND VPWR VPWR sky130_fd_sc_hd__decap_3
XTAP_TAPCELL_ROW_84_1260 VGND VPWR sky130_fd_sc_hd__tapvpwrvgnd_1
XPHY_EDGE_ROW_105_Right_105 VGND VGND VPWR VPWR sky130_fd_sc_hd__decap_3
XFILLER_111_60 VGND VGND VPWR VPWR sky130_fd_sc_hd__decap_3
XFILLER_13_521 VGND VGND VPWR VPWR sky130_fd_sc_hd__fill_2
XFILLER_111_93 VGND VGND VPWR VPWR sky130_fd_sc_hd__decap_3
XFILLER_40_340 VGND VGND VPWR VPWR sky130_fd_sc_hd__decap_3
XFILLER_71_53 VGND VGND VPWR VPWR sky130_fd_sc_hd__decap_3
XFILLER_9_503 VGND VGND VPWR VPWR sky130_fd_sc_hd__fill_1
XFILLER_65_9 VGND VGND VPWR VPWR sky130_fd_sc_hd__decap_3
XFILLER_114_607 VGND VGND VPWR VPWR sky130_fd_sc_hd__decap_3
XFILLER_4_241 VGND VGND VPWR VPWR sky130_fd_sc_hd__fill_1
XFILLER_113_128 VGND VGND VPWR VPWR sky130_fd_sc_hd__decap_3
XFILLER_4_274 VGND VGND VPWR VPWR sky130_fd_sc_hd__decap_3
XFILLER_106_191 VGND VGND VPWR VPWR sky130_fd_sc_hd__decap_3
XFILLER_95_546 VGND VGND VPWR VPWR sky130_fd_sc_hd__decap_3
XFILLER_96_94 VGND VGND VPWR VPWR sky130_fd_sc_hd__fill_1
XFILLER_63_421 VGND VGND VPWR VPWR sky130_fd_sc_hd__decap_3
XFILLER_75_281 VGND VGND VPWR VPWR sky130_fd_sc_hd__decap_3
XFILLER_82_218 VGND VGND VPWR VPWR sky130_fd_sc_hd__decap_3
XFILLER_82_229 VGND VGND VPWR VPWR sky130_fd_sc_hd__decap_3
XFILLER_35_134 VGND VGND VPWR VPWR sky130_fd_sc_hd__decap_3
XFILLER_51_605 VGND VGND VPWR VPWR sky130_fd_sc_hd__decap_3
Xplace410 _4419_/B1 VGND VGND VPWR VPWR _4429_/B1 sky130_fd_sc_hd__buf_2
Xplace421 _3945_/S VGND VGND VPWR VPWR _3935_/S sky130_fd_sc_hd__buf_2
XFILLER_23_307 VGND VGND VPWR VPWR sky130_fd_sc_hd__fill_2
XFILLER_23_318 VGND VGND VPWR VPWR sky130_fd_sc_hd__decap_3
XFILLER_35_167 VGND VGND VPWR VPWR sky130_fd_sc_hd__fill_1
XFILLER_35_178 VGND VGND VPWR VPWR sky130_fd_sc_hd__decap_3
XFILLER_51_638 VGND VGND VPWR VPWR sky130_fd_sc_hd__decap_3
XFILLER_63_476 VGND VGND VPWR VPWR sky130_fd_sc_hd__decap_3
XFILLER_90_262 VGND VGND VPWR VPWR sky130_fd_sc_hd__decap_3
Xplace432 _4261_/B1 VGND VGND VPWR VPWR _4430_/B1 sky130_fd_sc_hd__buf_2
Xplace443 _5587_/B VGND VGND VPWR VPWR _5598_/A2 sky130_fd_sc_hd__buf_2
Xplace454 _3561_/A VGND VGND VPWR VPWR _3342_/B sky130_fd_sc_hd__buf_2
X_6740_ _6976_/CLK _6740_/D VGND VGND VPWR VPWR _6740_/Q sky130_fd_sc_hd__dfxtp_2
XFILLER_16_392 VGND VGND VPWR VPWR sky130_fd_sc_hd__decap_3
XFILLER_50_126 VGND VGND VPWR VPWR sky130_fd_sc_hd__decap_3
XFILLER_90_295 VGND VGND VPWR VPWR sky130_fd_sc_hd__decap_3
X_3952_ _7364_/Q _4495_/A0 _3962_/S VGND VGND VPWR VPWR _7364_/D sky130_fd_sc_hd__mux2_2
XFILLER_31_351 VGND VGND VPWR VPWR sky130_fd_sc_hd__fill_2
X_6671_ _6672_/A VGND VGND VPWR VPWR _6671_/Y sky130_fd_sc_hd__inv_2
X_3883_ _6814_/Q _3883_/A2 _3883_/B1 _6819_/Q VGND VGND VPWR VPWR _3883_/X sky130_fd_sc_hd__a22o_2
XTAP_TAPCELL_ROW_21_508 VGND VPWR sky130_fd_sc_hd__tapvpwrvgnd_1
X_5622_ _5622_/A _5622_/B VGND VGND VPWR VPWR _7017_/D sky130_fd_sc_hd__nor2_2
XTAP_TAPCELL_ROW_98_1429 VGND VPWR sky130_fd_sc_hd__tapvpwrvgnd_1
XFILLER_105_607 VGND VGND VPWR VPWR sky130_fd_sc_hd__decap_3
XFILLER_104_106 VGND VGND VPWR VPWR sky130_fd_sc_hd__decap_3
XFILLER_104_128 VGND VGND VPWR VPWR sky130_fd_sc_hd__decap_3
XFILLER_105_629 VGND VGND VPWR VPWR sky130_fd_sc_hd__decap_3
X_7223_ _7352_/CLK _7223_/D _6503_/Y VGND VGND VPWR VPWR _7223_/Q sky130_fd_sc_hd__dfrtp_2
X_4435_ _7207_/Q _3945_/S _4435_/B1 _7367_/Q VGND VGND VPWR VPWR _4435_/X sky130_fd_sc_hd__a22o_2
XFILLER_116_38 VGND VGND VPWR VPWR sky130_fd_sc_hd__decap_3
X_7154_ _7352_/CLK _7154_/D _6434_/Y VGND VGND VPWR VPWR _7154_/Q sky130_fd_sc_hd__dfrtp_2
X_4366_ _4460_/A _4364_/Y _4313_/D _4361_/A _4365_/X VGND VGND VPWR VPWR _4366_/X
+ sky130_fd_sc_hd__a32o_2
XFILLER_98_340 VGND VGND VPWR VPWR sky130_fd_sc_hd__decap_3
XFILLER_112_150 VGND VGND VPWR VPWR sky130_fd_sc_hd__decap_3
XFILLER_113_662 VGND VGND VPWR VPWR sky130_fd_sc_hd__decap_3
XFILLER_113_673 VGND VGND VPWR VPWR sky130_fd_sc_hd__decap_3
XFILLER_58_215 VGND VGND VPWR VPWR sky130_fd_sc_hd__decap_3
XFILLER_86_513 VGND VGND VPWR VPWR sky130_fd_sc_hd__decap_3
XFILLER_86_524 VGND VGND VPWR VPWR sky130_fd_sc_hd__decap_3
XFILLER_112_183 VGND VGND VPWR VPWR sky130_fd_sc_hd__decap_3
XFILLER_58_248 VGND VGND VPWR VPWR sky130_fd_sc_hd__decap_3
X_7085_ _7234_/CLK _7085_/D _6365_/Y VGND VGND VPWR VPWR _7085_/Q sky130_fd_sc_hd__dfrtp_2
X_4297_ _5113_/A _4297_/B VGND VGND VPWR VPWR _4297_/Y sky130_fd_sc_hd__nor2_2
XFILLER_39_440 VGND VGND VPWR VPWR sky130_fd_sc_hd__decap_3
XFILLER_73_207 VGND VGND VPWR VPWR sky130_fd_sc_hd__decap_3
XFILLER_100_389 VGND VGND VPWR VPWR sky130_fd_sc_hd__decap_3
XFILLER_39_473 VGND VGND VPWR VPWR sky130_fd_sc_hd__decap_3
XFILLER_54_410 VGND VGND VPWR VPWR sky130_fd_sc_hd__decap_3
XFILLER_54_421 VGND VGND VPWR VPWR sky130_fd_sc_hd__decap_3
XTAP_TAPCELL_ROW_57_939 VGND VPWR sky130_fd_sc_hd__tapvpwrvgnd_1
XFILLER_27_668 VGND VGND VPWR VPWR sky130_fd_sc_hd__decap_3
XTAP_TAPCELL_ROW_1_266 VGND VPWR sky130_fd_sc_hd__tapvpwrvgnd_1
XTAP_TAPCELL_ROW_107_1536 VGND VPWR sky130_fd_sc_hd__tapvpwrvgnd_1
XFILLER_25_57 VGND VGND VPWR VPWR sky130_fd_sc_hd__decap_3
X_6938_ _7405_/CLK _6938_/D VGND VGND VPWR VPWR _6938_/Q sky130_fd_sc_hd__dfxtp_2
XTAP_TAPCELL_ROW_37_696 VGND VPWR sky130_fd_sc_hd__tapvpwrvgnd_1
XFILLER_50_660 VGND VGND VPWR VPWR sky130_fd_sc_hd__decap_3
X_6869_ clkload2/A _6869_/D VGND VGND VPWR VPWR _6869_/Q sky130_fd_sc_hd__dfxtp_2
XFILLER_41_23 VGND VGND VPWR VPWR sky130_fd_sc_hd__decap_3
XFILLER_41_78 VGND VGND VPWR VPWR sky130_fd_sc_hd__decap_3
XFILLER_104_640 VGND VGND VPWR VPWR sky130_fd_sc_hd__decap_3
XFILLER_104_651 VGND VGND VPWR VPWR sky130_fd_sc_hd__decap_3
XFILLER_89_340 VGND VGND VPWR VPWR sky130_fd_sc_hd__decap_3
XTAP_TAPCELL_ROW_9_355 VGND VPWR sky130_fd_sc_hd__tapvpwrvgnd_1
XFILLER_9_3 VGND VGND VPWR VPWR sky130_fd_sc_hd__decap_3
XFILLER_104_684 VGND VGND VPWR VPWR sky130_fd_sc_hd__decap_3
XFILLER_110_109 VGND VGND VPWR VPWR sky130_fd_sc_hd__decap_3
XFILLER_2_17 VGND VGND VPWR VPWR sky130_fd_sc_hd__decap_3
XFILLER_89_362 VGND VGND VPWR VPWR sky130_fd_sc_hd__decap_3
Xhold591 _6796_/Q VGND VGND VPWR VPWR _6796_/D sky130_fd_sc_hd__dlygate4sd3_1
XFILLER_106_71 VGND VGND VPWR VPWR sky130_fd_sc_hd__decap_3
XFILLER_49_248 VGND VGND VPWR VPWR sky130_fd_sc_hd__decap_3
XFILLER_89_384 VGND VGND VPWR VPWR sky130_fd_sc_hd__decap_3
XFILLER_106_93 VGND VGND VPWR VPWR sky130_fd_sc_hd__fill_2
XFILLER_66_42 VGND VGND VPWR VPWR sky130_fd_sc_hd__decap_3
XFILLER_57_281 VGND VGND VPWR VPWR sky130_fd_sc_hd__decap_3
XFILLER_66_75 VGND VGND VPWR VPWR sky130_fd_sc_hd__decap_3
XFILLER_17_145 VGND VGND VPWR VPWR sky130_fd_sc_hd__decap_3
XFILLER_72_240 VGND VGND VPWR VPWR sky130_fd_sc_hd__decap_3
XFILLER_82_41 VGND VGND VPWR VPWR sky130_fd_sc_hd__decap_3
XFILLER_26_690 VGND VGND VPWR VPWR sky130_fd_sc_hd__fill_2
XFILLER_82_74 VGND VGND VPWR VPWR sky130_fd_sc_hd__decap_3
XFILLER_82_96 VGND VGND VPWR VPWR sky130_fd_sc_hd__decap_3
XFILLER_40_170 VGND VGND VPWR VPWR sky130_fd_sc_hd__decap_3
XFILLER_41_671 VGND VGND VPWR VPWR sky130_fd_sc_hd__fill_1
XFILLER_41_682 VGND VGND VPWR VPWR sky130_fd_sc_hd__decap_3
XFILLER_40_181 VGND VGND VPWR VPWR sky130_fd_sc_hd__decap_3
XFILLER_9_355 VGND VGND VPWR VPWR sky130_fd_sc_hd__fill_1
XFILLER_9_399 VGND VGND VPWR VPWR sky130_fd_sc_hd__decap_3
XFILLER_9_388 VGND VGND VPWR VPWR sky130_fd_sc_hd__decap_3
XFILLER_5_561 VGND VGND VPWR VPWR sky130_fd_sc_hd__decap_3
XFILLER_114_459 VGND VGND VPWR VPWR sky130_fd_sc_hd__decap_3
X_4220_ _7196_/Q _4268_/A2 _4354_/B1 _7388_/Q VGND VGND VPWR VPWR _4220_/X sky130_fd_sc_hd__a22o_2
XFILLER_99_159 VGND VGND VPWR VPWR sky130_fd_sc_hd__fill_1
XFILLER_110_610 VGND VGND VPWR VPWR sky130_fd_sc_hd__decap_3
XFILLER_110_643 VGND VGND VPWR VPWR sky130_fd_sc_hd__fill_1
X_4151_ _7019_/Q _4418_/A2 _3954_/S _7202_/Q _4150_/X VGND VGND VPWR VPWR _4151_/X
+ sky130_fd_sc_hd__a221o_2
XFILLER_110_654 VGND VGND VPWR VPWR sky130_fd_sc_hd__decap_3
XFILLER_55_207 VGND VGND VPWR VPWR sky130_fd_sc_hd__fill_1
XFILLER_68_568 VGND VGND VPWR VPWR sky130_fd_sc_hd__decap_3
XFILLER_83_505 VGND VGND VPWR VPWR sky130_fd_sc_hd__decap_3
XFILLER_83_516 VGND VGND VPWR VPWR sky130_fd_sc_hd__decap_3
XFILLER_95_343 VGND VGND VPWR VPWR sky130_fd_sc_hd__decap_3
XFILLER_95_365 VGND VGND VPWR VPWR sky130_fd_sc_hd__decap_3
X_4082_ _4082_/A _4068_/A VGND VGND VPWR VPWR _4082_/X sky130_fd_sc_hd__or2b_2
XFILLER_110_687 VGND VGND VPWR VPWR sky130_fd_sc_hd__decap_3
XFILLER_48_270 VGND VGND VPWR VPWR sky130_fd_sc_hd__decap_3
XFILLER_55_218 VGND VGND VPWR VPWR sky130_fd_sc_hd__decap_3
XFILLER_102_18 VGND VGND VPWR VPWR sky130_fd_sc_hd__decap_3
XFILLER_102_29 VGND VGND VPWR VPWR sky130_fd_sc_hd__decap_3
XFILLER_51_402 VGND VGND VPWR VPWR sky130_fd_sc_hd__decap_3
XFILLER_63_273 VGND VGND VPWR VPWR sky130_fd_sc_hd__decap_3
XFILLER_51_435 VGND VGND VPWR VPWR sky130_fd_sc_hd__fill_2
XFILLER_63_284 VGND VGND VPWR VPWR sky130_fd_sc_hd__decap_3
Xplace273 _3902_/A2 VGND VGND VPWR VPWR _3926_/A2 sky130_fd_sc_hd__buf_2
X_4984_ _5099_/A _4619_/Y _4624_/A VGND VGND VPWR VPWR _5031_/B sky130_fd_sc_hd__a21o_2
Xplace295 _3889_/A2 VGND VGND VPWR VPWR _3882_/A2 sky130_fd_sc_hd__buf_2
Xplace284 _3887_/A2 VGND VGND VPWR VPWR _3925_/A2 sky130_fd_sc_hd__buf_2
X_6723_ _6978_/CLK _6723_/D VGND VGND VPWR VPWR _6723_/Q sky130_fd_sc_hd__dfxtp_2
X_3935_ _7372_/Q _4478_/A0 _3935_/S VGND VGND VPWR VPWR _7372_/D sky130_fd_sc_hd__mux2_2
XTAP_TAPCELL_ROW_34_655 VGND VPWR sky130_fd_sc_hd__tapvpwrvgnd_1
X_6654_ _6683_/A VGND VGND VPWR VPWR _6654_/Y sky130_fd_sc_hd__inv_2
XTAP_TAPCELL_ROW_62_997 VGND VPWR sky130_fd_sc_hd__tapvpwrvgnd_1
XTAP_TAPCELL_ROW_102_1477 VGND VPWR sky130_fd_sc_hd__tapvpwrvgnd_1
XFILLER_31_181 VGND VGND VPWR VPWR sky130_fd_sc_hd__decap_3
X_5605_ _5605_/A _5622_/B VGND VGND VPWR VPWR _7025_/D sky130_fd_sc_hd__or2_2
X_3866_ _6696_/Q _6786_/Q _6874_/Q _6922_/Q _3991_/B _3665_/B VGND VGND VPWR VPWR
+ _3866_/X sky130_fd_sc_hd__mux4_2
XPHY_EDGE_ROW_12_Left_129 VGND VGND VPWR VPWR sky130_fd_sc_hd__decap_3
XFILLER_11_15 VGND VGND VPWR VPWR sky130_fd_sc_hd__decap_3
X_6585_ _6617_/A VGND VGND VPWR VPWR _6585_/Y sky130_fd_sc_hd__inv_2
X_3797_ _6750_/Q _3892_/A2 _3893_/B1 _6732_/Q VGND VGND VPWR VPWR _3797_/X sky130_fd_sc_hd__a22o_2
XFILLER_11_48 VGND VGND VPWR VPWR sky130_fd_sc_hd__decap_3
XFILLER_105_437 VGND VGND VPWR VPWR sky130_fd_sc_hd__decap_3
X_7206_ _7334_/CLK _7206_/D _6486_/Y VGND VGND VPWR VPWR _7206_/Q sky130_fd_sc_hd__dfrtp_2
X_4418_ _7023_/Q _4418_/A2 _4417_/X VGND VGND VPWR VPWR _4425_/C sky130_fd_sc_hd__a21o_2
X_5398_ _5398_/A0 _4997_/X _5429_/S VGND VGND VPWR VPWR _7134_/D sky130_fd_sc_hd__mux2_2
XTAP_TAPCELL_ROW_6_325 VGND VPWR sky130_fd_sc_hd__tapvpwrvgnd_1
XFILLER_99_682 VGND VGND VPWR VPWR sky130_fd_sc_hd__decap_3
XFILLER_99_671 VGND VGND VPWR VPWR sky130_fd_sc_hd__fill_1
XFILLER_101_610 VGND VGND VPWR VPWR sky130_fd_sc_hd__decap_3
XFILLER_101_632 VGND VGND VPWR VPWR sky130_fd_sc_hd__decap_3
X_7137_ _7363_/CLK _7137_/D _6417_/Y VGND VGND VPWR VPWR _7137_/Q sky130_fd_sc_hd__dfrtp_2
X_4349_ _7257_/Q _4418_/A2 _4349_/B1 _7225_/Q _4348_/X VGND VGND VPWR VPWR _4367_/A
+ sky130_fd_sc_hd__a221o_2
XFILLER_100_131 VGND VGND VPWR VPWR sky130_fd_sc_hd__fill_2
XFILLER_101_665 VGND VGND VPWR VPWR sky130_fd_sc_hd__decap_3
XFILLER_101_676 VGND VGND VPWR VPWR sky130_fd_sc_hd__decap_3
XFILLER_86_365 VGND VGND VPWR VPWR sky130_fd_sc_hd__fill_2
X_7068_ clkload7/A _7068_/D _6348_/Y VGND VGND VPWR VPWR _7068_/Q sky130_fd_sc_hd__dfrtp_2
XPHY_EDGE_ROW_21_Left_138 VGND VGND VPWR VPWR sky130_fd_sc_hd__decap_3
XFILLER_100_186 VGND VGND VPWR VPWR sky130_fd_sc_hd__fill_2
XFILLER_27_410 VGND VGND VPWR VPWR sky130_fd_sc_hd__fill_1
XFILLER_36_12 VGND VGND VPWR VPWR sky130_fd_sc_hd__decap_3
XFILLER_46_218 VGND VGND VPWR VPWR sky130_fd_sc_hd__decap_3
XFILLER_74_527 VGND VGND VPWR VPWR sky130_fd_sc_hd__decap_3
XFILLER_86_398 VGND VGND VPWR VPWR sky130_fd_sc_hd__decap_3
XFILLER_100_197 VGND VGND VPWR VPWR sky130_fd_sc_hd__decap_3
XFILLER_39_281 VGND VGND VPWR VPWR sky130_fd_sc_hd__decap_3
XFILLER_42_413 VGND VGND VPWR VPWR sky130_fd_sc_hd__decap_3
XFILLER_54_262 VGND VGND VPWR VPWR sky130_fd_sc_hd__decap_3
XTAP_TAPCELL_ROW_68_1063 VGND VPWR sky130_fd_sc_hd__tapvpwrvgnd_1
XFILLER_14_126 VGND VGND VPWR VPWR sky130_fd_sc_hd__decap_3
XFILLER_42_435 VGND VGND VPWR VPWR sky130_fd_sc_hd__decap_3
XFILLER_54_284 VGND VGND VPWR VPWR sky130_fd_sc_hd__decap_3
XFILLER_42_457 VGND VGND VPWR VPWR sky130_fd_sc_hd__decap_3
XFILLER_52_11 VGND VGND VPWR VPWR sky130_fd_sc_hd__decap_3
XFILLER_23_671 VGND VGND VPWR VPWR sky130_fd_sc_hd__fill_1
XFILLER_52_44 VGND VGND VPWR VPWR sky130_fd_sc_hd__decap_3
XFILLER_52_55 VGND VGND VPWR VPWR sky130_fd_sc_hd__decap_3
XPHY_EDGE_ROW_30_Left_147 VGND VGND VPWR VPWR sky130_fd_sc_hd__decap_3
XFILLER_10_321 VGND VGND VPWR VPWR sky130_fd_sc_hd__decap_3
XFILLER_10_365 VGND VGND VPWR VPWR sky130_fd_sc_hd__decap_3
XFILLER_108_253 VGND VGND VPWR VPWR sky130_fd_sc_hd__fill_1
XFILLER_2_564 VGND VGND VPWR VPWR sky130_fd_sc_hd__fill_2
XFILLER_96_118 VGND VGND VPWR VPWR sky130_fd_sc_hd__decap_3
XFILLER_2_586 VGND VGND VPWR VPWR sky130_fd_sc_hd__fill_2
XFILLER_77_310 VGND VGND VPWR VPWR sky130_fd_sc_hd__fill_1
XFILLER_77_41 VGND VGND VPWR VPWR sky130_fd_sc_hd__fill_2
XFILLER_77_63 VGND VGND VPWR VPWR sky130_fd_sc_hd__fill_2
XFILLER_28_9 VGND VGND VPWR VPWR sky130_fd_sc_hd__decap_3
XFILLER_65_505 VGND VGND VPWR VPWR sky130_fd_sc_hd__fill_2
XFILLER_77_85 VGND VGND VPWR VPWR sky130_fd_sc_hd__decap_3
XFILLER_37_207 VGND VGND VPWR VPWR sky130_fd_sc_hd__decap_3
XFILLER_77_376 VGND VGND VPWR VPWR sky130_fd_sc_hd__decap_3
XFILLER_18_432 VGND VGND VPWR VPWR sky130_fd_sc_hd__fill_2
XFILLER_92_335 VGND VGND VPWR VPWR sky130_fd_sc_hd__decap_3
XFILLER_93_40 VGND VGND VPWR VPWR sky130_fd_sc_hd__decap_3
XFILLER_18_454 VGND VGND VPWR VPWR sky130_fd_sc_hd__decap_3
XFILLER_45_240 VGND VGND VPWR VPWR sky130_fd_sc_hd__decap_3
XFILLER_80_519 VGND VGND VPWR VPWR sky130_fd_sc_hd__decap_3
XFILLER_93_73 VGND VGND VPWR VPWR sky130_fd_sc_hd__decap_3
XFILLER_33_424 VGND VGND VPWR VPWR sky130_fd_sc_hd__decap_3
XFILLER_33_435 VGND VGND VPWR VPWR sky130_fd_sc_hd__fill_1
XFILLER_45_284 VGND VGND VPWR VPWR sky130_fd_sc_hd__decap_3
XFILLER_60_221 VGND VGND VPWR VPWR sky130_fd_sc_hd__decap_3
XFILLER_33_468 VGND VGND VPWR VPWR sky130_fd_sc_hd__decap_3
XFILLER_60_243 VGND VGND VPWR VPWR sky130_fd_sc_hd__decap_3
XFILLER_60_265 VGND VGND VPWR VPWR sky130_fd_sc_hd__decap_3
X_3720_ _6911_/Q _3879_/A2 _3888_/B1 _6903_/Q VGND VGND VPWR VPWR _3720_/X sky130_fd_sc_hd__a22o_2
XTAP_TAPCELL_ROW_31_625 VGND VPWR sky130_fd_sc_hd__tapvpwrvgnd_1
Xclkbuf_leaf_40_clk clkbuf_leaf_1_clk/A VGND VGND VPWR VPWR _7312_/CLK sky130_fd_sc_hd__clkbuf_16
X_3651_ _3665_/A _3665_/B VGND VGND VPWR VPWR _3651_/Y sky130_fd_sc_hd__nor2_2
XFILLER_61_3 VGND VGND VPWR VPWR sky130_fd_sc_hd__decap_3
X_6370_ _6568_/A VGND VGND VPWR VPWR _6370_/Y sky130_fd_sc_hd__inv_2
X_3582_ _7348_/Q _3449_/X _3407_/X _7124_/Q VGND VGND VPWR VPWR _3583_/C sky130_fd_sc_hd__a22o_2
XTAP_TAPCELL_ROW_11_382 VGND VPWR sky130_fd_sc_hd__tapvpwrvgnd_1
X_5321_ _5321_/A0 _4932_/X _7412_/A VGND VGND VPWR VPWR _7170_/D sky130_fd_sc_hd__mux2_2
XFILLER_114_212 VGND VGND VPWR VPWR sky130_fd_sc_hd__decap_3
XFILLER_114_245 VGND VGND VPWR VPWR sky130_fd_sc_hd__decap_3
XFILLER_5_391 VGND VGND VPWR VPWR sky130_fd_sc_hd__fill_1
XFILLER_88_608 VGND VGND VPWR VPWR sky130_fd_sc_hd__decap_3
XFILLER_102_418 VGND VGND VPWR VPWR sky130_fd_sc_hd__fill_2
XFILLER_114_256 VGND VGND VPWR VPWR sky130_fd_sc_hd__decap_3
XFILLER_87_107 VGND VGND VPWR VPWR sky130_fd_sc_hd__decap_3
XFILLER_114_289 VGND VGND VPWR VPWR sky130_fd_sc_hd__decap_3
X_4203_ _4203_/A _4203_/B _4203_/C VGND VGND VPWR VPWR _4203_/X sky130_fd_sc_hd__and3_2
XFILLER_3_60 VGND VGND VPWR VPWR sky130_fd_sc_hd__decap_3
XFILLER_68_365 VGND VGND VPWR VPWR sky130_fd_sc_hd__decap_3
XFILLER_96_641 VGND VGND VPWR VPWR sky130_fd_sc_hd__decap_3
XFILLER_96_663 VGND VGND VPWR VPWR sky130_fd_sc_hd__decap_3
X_4134_ _7020_/Q _4422_/A2 _3954_/S _7203_/Q _4133_/X VGND VGND VPWR VPWR _4134_/X
+ sky130_fd_sc_hd__a221o_2
XFILLER_3_93 VGND VGND VPWR VPWR sky130_fd_sc_hd__decap_3
XFILLER_68_387 VGND VGND VPWR VPWR sky130_fd_sc_hd__decap_3
XFILLER_83_302 VGND VGND VPWR VPWR sky130_fd_sc_hd__fill_1
XFILLER_95_184 VGND VGND VPWR VPWR sky130_fd_sc_hd__decap_3
XTAP_TAPCELL_ROW_39_725 VGND VPWR sky130_fd_sc_hd__tapvpwrvgnd_1
XTAP_TAPCELL_ROW_39_714 VGND VPWR sky130_fd_sc_hd__tapvpwrvgnd_1
XFILLER_113_39 VGND VGND VPWR VPWR sky130_fd_sc_hd__decap_3
XFILLER_95_195 VGND VGND VPWR VPWR sky130_fd_sc_hd__decap_3
X_4065_ _7052_/Q _4482_/S _4437_/B1 _7404_/Q _4064_/X VGND VGND VPWR VPWR _4065_/X
+ sky130_fd_sc_hd__a221o_2
XFILLER_64_560 VGND VGND VPWR VPWR sky130_fd_sc_hd__decap_3
XFILLER_71_508 VGND VGND VPWR VPWR sky130_fd_sc_hd__fill_1
XFILLER_71_519 VGND VGND VPWR VPWR sky130_fd_sc_hd__decap_3
XFILLER_24_413 VGND VGND VPWR VPWR sky130_fd_sc_hd__decap_3
XFILLER_24_424 VGND VGND VPWR VPWR sky130_fd_sc_hd__decap_3
XFILLER_36_273 VGND VGND VPWR VPWR sky130_fd_sc_hd__fill_1
XFILLER_36_295 VGND VGND VPWR VPWR sky130_fd_sc_hd__decap_3
XTAP_TAPCELL_ROW_19_482 VGND VPWR sky130_fd_sc_hd__tapvpwrvgnd_1
XFILLER_51_276 VGND VGND VPWR VPWR sky130_fd_sc_hd__decap_3
X_4967_ _4967_/A _4967_/B VGND VGND VPWR VPWR _4967_/X sky130_fd_sc_hd__or2_2
Xclkbuf_leaf_31_clk clkbuf_3_2__f_clk/X VGND VGND VPWR VPWR _6970_/CLK sky130_fd_sc_hd__clkbuf_16
X_6706_ _7406_/CLK _6706_/D VGND VGND VPWR VPWR _6706_/Q sky130_fd_sc_hd__dfxtp_2
X_4898_ _3757_/S _3756_/X _4897_/X _5010_/A VGND VGND VPWR VPWR _4898_/X sky130_fd_sc_hd__a211o_2
X_3918_ _6915_/Q _3926_/A2 _3926_/B1 _6779_/Q _3917_/X VGND VGND VPWR VPWR _3918_/X
+ sky130_fd_sc_hd__a221o_2
XFILLER_22_58 VGND VGND VPWR VPWR sky130_fd_sc_hd__decap_3
X_6637_ _6637_/A VGND VGND VPWR VPWR _6637_/Y sky130_fd_sc_hd__inv_2
X_3849_ _6859_/Q _3913_/A2 _3883_/B1 _6899_/Q _3848_/X VGND VGND VPWR VPWR _3849_/X
+ sky130_fd_sc_hd__a221o_2
X_6568_ _6568_/A VGND VGND VPWR VPWR _6568_/Y sky130_fd_sc_hd__inv_2
XTAP_TAPCELL_ROW_115_1635 VGND VPWR sky130_fd_sc_hd__tapvpwrvgnd_1
XFILLER_98_29 VGND VGND VPWR VPWR sky130_fd_sc_hd__fill_2
XFILLER_98_18 VGND VGND VPWR VPWR sky130_fd_sc_hd__fill_1
X_6499_ _6599_/A VGND VGND VPWR VPWR _6499_/Y sky130_fd_sc_hd__inv_2
XFILLER_105_267 VGND VGND VPWR VPWR sky130_fd_sc_hd__fill_2
XFILLER_105_278 VGND VGND VPWR VPWR sky130_fd_sc_hd__fill_2
XFILLER_78_107 VGND VGND VPWR VPWR sky130_fd_sc_hd__decap_3
XFILLER_79_608 VGND VGND VPWR VPWR sky130_fd_sc_hd__decap_3
Xoutput471 _5662_/C VGND VGND VPWR VPWR alu_result_out[17] sky130_fd_sc_hd__clkdlybuf4s25_1
XFILLER_59_321 VGND VGND VPWR VPWR sky130_fd_sc_hd__decap_3
Xoutput493 _5651_/Y VGND VGND VPWR VPWR alu_result_out[8] sky130_fd_sc_hd__clkdlybuf4s25_1
Xoutput482 _5652_/Y VGND VGND VPWR VPWR alu_result_out[27] sky130_fd_sc_hd__clkdlybuf4s25_1
XFILLER_47_505 VGND VGND VPWR VPWR sky130_fd_sc_hd__fill_2
XFILLER_87_641 VGND VGND VPWR VPWR sky130_fd_sc_hd__decap_3
XFILLER_47_33 VGND VGND VPWR VPWR sky130_fd_sc_hd__fill_1
XFILLER_47_55 VGND VGND VPWR VPWR sky130_fd_sc_hd__fill_1
XFILLER_87_685 VGND VGND VPWR VPWR sky130_fd_sc_hd__decap_3
XFILLER_47_549 VGND VGND VPWR VPWR sky130_fd_sc_hd__decap_3
XFILLER_15_402 VGND VGND VPWR VPWR sky130_fd_sc_hd__decap_3
XFILLER_27_240 VGND VGND VPWR VPWR sky130_fd_sc_hd__decap_3
XFILLER_74_368 VGND VGND VPWR VPWR sky130_fd_sc_hd__decap_3
XFILLER_103_72 VGND VGND VPWR VPWR sky130_fd_sc_hd__decap_3
XFILLER_27_284 VGND VGND VPWR VPWR sky130_fd_sc_hd__decap_3
XFILLER_42_210 VGND VGND VPWR VPWR sky130_fd_sc_hd__decap_3
XFILLER_55_582 VGND VGND VPWR VPWR sky130_fd_sc_hd__decap_3
XFILLER_82_390 VGND VGND VPWR VPWR sky130_fd_sc_hd__decap_3
XFILLER_42_243 VGND VGND VPWR VPWR sky130_fd_sc_hd__decap_3
XFILLER_70_552 VGND VGND VPWR VPWR sky130_fd_sc_hd__fill_2
XFILLER_42_265 VGND VGND VPWR VPWR sky130_fd_sc_hd__decap_3
XFILLER_70_574 VGND VGND VPWR VPWR sky130_fd_sc_hd__fill_1
XFILLER_8_38 VGND VGND VPWR VPWR sky130_fd_sc_hd__decap_3
Xclkbuf_leaf_22_clk clkbuf_3_6__f_clk/X VGND VGND VPWR VPWR _7392_/CLK sky130_fd_sc_hd__clkbuf_16
XFILLER_11_685 VGND VGND VPWR VPWR sky130_fd_sc_hd__decap_3
XFILLER_6_100 VGND VGND VPWR VPWR sky130_fd_sc_hd__decap_3
XFILLER_109_551 VGND VGND VPWR VPWR sky130_fd_sc_hd__fill_1
XFILLER_10_184 VGND VGND VPWR VPWR sky130_fd_sc_hd__decap_3
XFILLER_6_133 VGND VGND VPWR VPWR sky130_fd_sc_hd__decap_3
XFILLER_6_144 VGND VGND VPWR VPWR sky130_fd_sc_hd__decap_3
Xwire554 _3749_/Y VGND VGND VPWR VPWR wire554/X sky130_fd_sc_hd__clkbuf_2
XFILLER_109_573 VGND VGND VPWR VPWR sky130_fd_sc_hd__decap_3
XFILLER_12_80 VGND VGND VPWR VPWR sky130_fd_sc_hd__decap_3
XTAP_TAPCELL_ROW_90_1329 VGND VPWR sky130_fd_sc_hd__tapvpwrvgnd_1
XFILLER_2_383 VGND VGND VPWR VPWR sky130_fd_sc_hd__decap_3
XFILLER_97_449 VGND VGND VPWR VPWR sky130_fd_sc_hd__fill_2
XFILLER_26_6 VGND VGND VPWR VPWR sky130_fd_sc_hd__decap_3
XFILLER_78_663 VGND VGND VPWR VPWR sky130_fd_sc_hd__decap_3
XFILLER_65_302 VGND VGND VPWR VPWR sky130_fd_sc_hd__decap_3
XFILLER_93_611 VGND VGND VPWR VPWR sky130_fd_sc_hd__decap_3
XFILLER_92_121 VGND VGND VPWR VPWR sky130_fd_sc_hd__decap_3
XFILLER_93_644 VGND VGND VPWR VPWR sky130_fd_sc_hd__decap_3
XFILLER_18_251 VGND VGND VPWR VPWR sky130_fd_sc_hd__fill_1
XFILLER_53_508 VGND VGND VPWR VPWR sky130_fd_sc_hd__decap_3
XFILLER_80_327 VGND VGND VPWR VPWR sky130_fd_sc_hd__decap_3
XFILLER_33_243 VGND VGND VPWR VPWR sky130_fd_sc_hd__decap_3
XFILLER_33_254 VGND VGND VPWR VPWR sky130_fd_sc_hd__decap_3
X_4821_ _4832_/A _3704_/X _4819_/X _5010_/A VGND VGND VPWR VPWR _4821_/X sky130_fd_sc_hd__a211o_2
XTAP_TAPCELL_ROW_16_441 VGND VPWR sky130_fd_sc_hd__tapvpwrvgnd_1
XFILLER_33_276 VGND VGND VPWR VPWR sky130_fd_sc_hd__decap_3
XFILLER_61_596 VGND VGND VPWR VPWR sky130_fd_sc_hd__decap_3
XTAP_TAPCELL_ROW_44_783 VGND VPWR sky130_fd_sc_hd__tapvpwrvgnd_1
XFILLER_21_449 VGND VGND VPWR VPWR sky130_fd_sc_hd__decap_3
Xclkbuf_leaf_13_clk clkbuf_leaf_9_clk/A VGND VGND VPWR VPWR _7402_/CLK sky130_fd_sc_hd__clkbuf_16
X_4752_ _4997_/A1 _7006_/D _4751_/Y VGND VGND VPWR VPWR _4752_/X sky130_fd_sc_hd__a21o_2
X_4683_ _6997_/Q _6998_/Q _5622_/B VGND VGND VPWR VPWR _4683_/X sky130_fd_sc_hd__o21a_2
X_3703_ _6938_/Q _3768_/A2 _3759_/A2 _6802_/Q VGND VGND VPWR VPWR _3703_/X sky130_fd_sc_hd__a22o_2
X_6422_ _6616_/A VGND VGND VPWR VPWR _6422_/Y sky130_fd_sc_hd__inv_2
X_3634_ _3636_/B _3631_/Y _3632_/X _3633_/Y VGND VGND VPWR VPWR _3634_/Y sky130_fd_sc_hd__o211ai_4
XFILLER_115_532 VGND VGND VPWR VPWR sky130_fd_sc_hd__decap_3
X_6353_ _6388_/A VGND VGND VPWR VPWR _6353_/Y sky130_fd_sc_hd__inv_2
X_3565_ wire568/X _3469_/B _3564_/X _3449_/A VGND VGND VPWR VPWR _5648_/B sky130_fd_sc_hd__o211a_2
XFILLER_0_309 VGND VGND VPWR VPWR sky130_fd_sc_hd__fill_1
XFILLER_115_576 VGND VGND VPWR VPWR sky130_fd_sc_hd__decap_3
X_6284_ _6285_/A VGND VGND VPWR VPWR _6284_/Y sky130_fd_sc_hd__inv_2
X_5304_ _5304_/A0 _4792_/X _5315_/S VGND VGND VPWR VPWR _7178_/D sky130_fd_sc_hd__mux2_2
X_3496_ _7215_/Q _3318_/B _5159_/S _7279_/Q _3495_/X VGND VGND VPWR VPWR _3496_/X
+ sky130_fd_sc_hd__a221o_2
XFILLER_88_427 VGND VGND VPWR VPWR sky130_fd_sc_hd__decap_3
XFILLER_102_248 VGND VGND VPWR VPWR sky130_fd_sc_hd__decap_3
XFILLER_102_259 VGND VGND VPWR VPWR sky130_fd_sc_hd__decap_3
XFILLER_69_641 VGND VGND VPWR VPWR sky130_fd_sc_hd__decap_3
XFILLER_29_505 VGND VGND VPWR VPWR sky130_fd_sc_hd__decap_3
XFILLER_29_516 VGND VGND VPWR VPWR sky130_fd_sc_hd__fill_1
XFILLER_68_173 VGND VGND VPWR VPWR sky130_fd_sc_hd__fill_2
XFILLER_69_685 VGND VGND VPWR VPWR sky130_fd_sc_hd__decap_3
XFILLER_84_622 VGND VGND VPWR VPWR sky130_fd_sc_hd__decap_3
XTAP_TAPCELL_ROW_110_1576 VGND VPWR sky130_fd_sc_hd__tapvpwrvgnd_1
XFILLER_110_292 VGND VGND VPWR VPWR sky130_fd_sc_hd__decap_3
XFILLER_29_538 VGND VGND VPWR VPWR sky130_fd_sc_hd__decap_3
XFILLER_68_184 VGND VGND VPWR VPWR sky130_fd_sc_hd__decap_3
X_5097_ _6985_/Q _5120_/A VGND VGND VPWR VPWR _5098_/B sky130_fd_sc_hd__nor2_2
X_4117_ _4205_/A _4117_/B _4117_/C VGND VGND VPWR VPWR _4117_/Y sky130_fd_sc_hd__nand3_2
XFILLER_17_36 VGND VGND VPWR VPWR sky130_fd_sc_hd__decap_3
XFILLER_44_508 VGND VGND VPWR VPWR sky130_fd_sc_hd__decap_3
XFILLER_56_357 VGND VGND VPWR VPWR sky130_fd_sc_hd__fill_1
XFILLER_71_316 VGND VGND VPWR VPWR sky130_fd_sc_hd__decap_3
XFILLER_83_143 VGND VGND VPWR VPWR sky130_fd_sc_hd__decap_3
XFILLER_83_165 VGND VGND VPWR VPWR sky130_fd_sc_hd__decap_3
XFILLER_84_666 VGND VGND VPWR VPWR sky130_fd_sc_hd__decap_3
X_4048_ _7117_/Q _4434_/A2 _4434_/B1 _7149_/Q VGND VGND VPWR VPWR _4048_/X sky130_fd_sc_hd__a22o_2
XFILLER_17_69 VGND VGND VPWR VPWR sky130_fd_sc_hd__decap_3
XFILLER_24_221 VGND VGND VPWR VPWR sky130_fd_sc_hd__decap_3
XTAP_TAPCELL_ROW_65_1033 VGND VPWR sky130_fd_sc_hd__tapvpwrvgnd_1
XFILLER_24_265 VGND VGND VPWR VPWR sky130_fd_sc_hd__decap_3
XFILLER_24_298 VGND VGND VPWR VPWR sky130_fd_sc_hd__fill_1
XFILLER_33_57 VGND VGND VPWR VPWR sky130_fd_sc_hd__decap_3
XPHY_EDGE_ROW_104_Left_221 VGND VGND VPWR VPWR sky130_fd_sc_hd__decap_3
XFILLER_4_626 VGND VGND VPWR VPWR sky130_fd_sc_hd__decap_3
XFILLER_109_3 VGND VGND VPWR VPWR sky130_fd_sc_hd__decap_3
XFILLER_3_125 VGND VGND VPWR VPWR sky130_fd_sc_hd__decap_3
XFILLER_4_648 VGND VGND VPWR VPWR sky130_fd_sc_hd__decap_3
XFILLER_3_158 VGND VGND VPWR VPWR sky130_fd_sc_hd__fill_2
XFILLER_3_169 VGND VGND VPWR VPWR sky130_fd_sc_hd__fill_1
XFILLER_79_405 VGND VGND VPWR VPWR sky130_fd_sc_hd__fill_2
XTAP_TAPCELL_ROW_76_1162 VGND VPWR sky130_fd_sc_hd__tapvpwrvgnd_1
XFILLER_58_21 VGND VGND VPWR VPWR sky130_fd_sc_hd__decap_3
XFILLER_79_449 VGND VGND VPWR VPWR sky130_fd_sc_hd__decap_3
XFILLER_47_302 VGND VGND VPWR VPWR sky130_fd_sc_hd__decap_3
XFILLER_75_611 VGND VGND VPWR VPWR sky130_fd_sc_hd__decap_3
XPHY_EDGE_ROW_113_Left_230 VGND VGND VPWR VPWR sky130_fd_sc_hd__decap_3
XFILLER_101_270 VGND VGND VPWR VPWR sky130_fd_sc_hd__decap_3
XFILLER_47_335 VGND VGND VPWR VPWR sky130_fd_sc_hd__fill_1
XFILLER_59_184 VGND VGND VPWR VPWR sky130_fd_sc_hd__decap_3
XFILLER_74_132 VGND VGND VPWR VPWR sky130_fd_sc_hd__fill_1
XFILLER_75_633 VGND VGND VPWR VPWR sky130_fd_sc_hd__decap_3
XFILLER_114_71 VGND VGND VPWR VPWR sky130_fd_sc_hd__decap_3
XFILLER_62_305 VGND VGND VPWR VPWR sky130_fd_sc_hd__decap_3
XFILLER_75_666 VGND VGND VPWR VPWR sky130_fd_sc_hd__decap_3
XFILLER_75_688 VGND VGND VPWR VPWR sky130_fd_sc_hd__decap_3
XFILLER_90_625 VGND VGND VPWR VPWR sky130_fd_sc_hd__decap_3
XFILLER_90_669 VGND VGND VPWR VPWR sky130_fd_sc_hd__decap_3
XTAP_TAPCELL_ROW_87_1291 VGND VPWR sky130_fd_sc_hd__tapvpwrvgnd_1
XFILLER_15_254 VGND VGND VPWR VPWR sky130_fd_sc_hd__decap_3
XFILLER_15_287 VGND VGND VPWR VPWR sky130_fd_sc_hd__decap_3
XFILLER_70_371 VGND VGND VPWR VPWR sky130_fd_sc_hd__decap_3
XFILLER_95_9 VGND VGND VPWR VPWR sky130_fd_sc_hd__decap_3
XFILLER_90_52 VGND VGND VPWR VPWR sky130_fd_sc_hd__decap_3
XTAP_TAPCELL_ROW_41_742 VGND VPWR sky130_fd_sc_hd__tapvpwrvgnd_1
XTAP_TAPCELL_ROW_13_411 VGND VPWR sky130_fd_sc_hd__tapvpwrvgnd_1
XFILLER_30_268 VGND VGND VPWR VPWR sky130_fd_sc_hd__decap_3
XFILLER_90_85 VGND VGND VPWR VPWR sky130_fd_sc_hd__decap_3
XFILLER_23_90 VGND VGND VPWR VPWR sky130_fd_sc_hd__decap_3
XFILLER_7_431 VGND VGND VPWR VPWR sky130_fd_sc_hd__decap_3
XFILLER_116_307 VGND VGND VPWR VPWR sky130_fd_sc_hd__fill_1
XFILLER_116_318 VGND VGND VPWR VPWR sky130_fd_sc_hd__decap_3
XFILLER_99_72 VGND VGND VPWR VPWR sky130_fd_sc_hd__decap_3
XFILLER_99_50 VGND VGND VPWR VPWR sky130_fd_sc_hd__decap_3
X_3350_ _6979_/Q _3350_/B VGND VGND VPWR VPWR _3350_/Y sky130_fd_sc_hd__nor2_2
XFILLER_3_670 VGND VGND VPWR VPWR sky130_fd_sc_hd__fill_2
XFILLER_97_202 VGND VGND VPWR VPWR sky130_fd_sc_hd__decap_3
XFILLER_112_557 VGND VGND VPWR VPWR sky130_fd_sc_hd__decap_3
XFILLER_97_257 VGND VGND VPWR VPWR sky130_fd_sc_hd__decap_3
X_5020_ _5020_/A _5020_/B _4373_/Y VGND VGND VPWR VPWR _5020_/X sky130_fd_sc_hd__or3b_2
XFILLER_66_622 VGND VGND VPWR VPWR sky130_fd_sc_hd__decap_3
XFILLER_78_471 VGND VGND VPWR VPWR sky130_fd_sc_hd__decap_3
XFILLER_85_419 VGND VGND VPWR VPWR sky130_fd_sc_hd__decap_3
XFILLER_97_279 VGND VGND VPWR VPWR sky130_fd_sc_hd__fill_1
Xclkbuf_leaf_2_clk clkbuf_leaf_4_clk/A VGND VGND VPWR VPWR _7294_/CLK sky130_fd_sc_hd__clkbuf_16
Xhold1109 _7338_/Q VGND VGND VPWR VPWR _4482_/A0 sky130_fd_sc_hd__dlygate4sd3_1
XFILLER_38_346 VGND VGND VPWR VPWR sky130_fd_sc_hd__fill_2
XFILLER_78_493 VGND VGND VPWR VPWR sky130_fd_sc_hd__fill_2
XTAP_TAPCELL_ROW_49_842 VGND VPWR sky130_fd_sc_hd__tapvpwrvgnd_1
XFILLER_38_357 VGND VGND VPWR VPWR sky130_fd_sc_hd__decap_3
XFILLER_38_368 VGND VGND VPWR VPWR sky130_fd_sc_hd__fill_2
XFILLER_38_379 VGND VGND VPWR VPWR sky130_fd_sc_hd__decap_3
XFILLER_65_165 VGND VGND VPWR VPWR sky130_fd_sc_hd__decap_3
XFILLER_66_666 VGND VGND VPWR VPWR sky130_fd_sc_hd__decap_3
XFILLER_93_452 VGND VGND VPWR VPWR sky130_fd_sc_hd__fill_1
XFILLER_93_474 VGND VGND VPWR VPWR sky130_fd_sc_hd__decap_3
XFILLER_0_50 VGND VGND VPWR VPWR sky130_fd_sc_hd__decap_3
XFILLER_19_593 VGND VGND VPWR VPWR sky130_fd_sc_hd__decap_3
XFILLER_53_316 VGND VGND VPWR VPWR sky130_fd_sc_hd__decap_3
XFILLER_81_647 VGND VGND VPWR VPWR sky130_fd_sc_hd__decap_3
X_6971_ _6971_/CLK _6971_/D VGND VGND VPWR VPWR _6971_/Q sky130_fd_sc_hd__dfxtp_2
XFILLER_0_83 VGND VGND VPWR VPWR sky130_fd_sc_hd__fill_1
XFILLER_80_135 VGND VGND VPWR VPWR sky130_fd_sc_hd__decap_3
XFILLER_110_18 VGND VGND VPWR VPWR sky130_fd_sc_hd__decap_3
XFILLER_110_29 VGND VGND VPWR VPWR sky130_fd_sc_hd__decap_3
XFILLER_21_202 VGND VGND VPWR VPWR sky130_fd_sc_hd__decap_3
XFILLER_21_246 VGND VGND VPWR VPWR sky130_fd_sc_hd__decap_3
XFILLER_61_393 VGND VGND VPWR VPWR sky130_fd_sc_hd__decap_3
X_4804_ _4804_/A _4804_/B VGND VGND VPWR VPWR _4804_/X sky130_fd_sc_hd__or2_2
X_4735_ _4735_/A0 _4734_/X _4837_/S VGND VGND VPWR VPWR _7277_/D sky130_fd_sc_hd__mux2_2
XFILLER_9_81 VGND VGND VPWR VPWR sky130_fd_sc_hd__decap_3
X_4666_ _6997_/Q _4667_/B VGND VGND VPWR VPWR _4908_/A sky130_fd_sc_hd__xnor2_2
X_7385_ _7392_/CLK _7385_/D _6665_/Y VGND VGND VPWR VPWR _7385_/Q sky130_fd_sc_hd__dfrtp_2
Xhold910 _6688_/Q VGND VGND VPWR VPWR hold910/X sky130_fd_sc_hd__dlygate4sd3_1
Xhold921 _6705_/Q VGND VGND VPWR VPWR hold921/X sky130_fd_sc_hd__dlygate4sd3_1
X_6405_ _6567_/A VGND VGND VPWR VPWR _6405_/Y sky130_fd_sc_hd__inv_2
X_4597_ _4597_/A0 _5140_/A0 _4601_/S VGND VGND VPWR VPWR _7282_/D sky130_fd_sc_hd__mux2_2
X_3617_ _4614_/C _3616_/B _5146_/B1 VGND VGND VPWR VPWR _3617_/X sky130_fd_sc_hd__o21a_2
XFILLER_115_340 VGND VGND VPWR VPWR sky130_fd_sc_hd__decap_3
Xhold932 _6691_/Q VGND VGND VPWR VPWR hold932/X sky130_fd_sc_hd__dlygate4sd3_1
Xhold954 _6717_/Q VGND VGND VPWR VPWR hold954/X sky130_fd_sc_hd__dlygate4sd3_1
Xhold943 _7041_/Q VGND VGND VPWR VPWR hold943/X sky130_fd_sc_hd__dlygate4sd3_1
X_6336_ _6347_/A VGND VGND VPWR VPWR _6336_/Y sky130_fd_sc_hd__inv_2
X_3548_ _3621_/A _4938_/A _5072_/A VGND VGND VPWR VPWR _3548_/X sky130_fd_sc_hd__or3_2
XFILLER_115_373 VGND VGND VPWR VPWR sky130_fd_sc_hd__decap_3
XFILLER_88_224 VGND VGND VPWR VPWR sky130_fd_sc_hd__fill_1
Xhold998 _7279_/Q VGND VGND VPWR VPWR hold998/X sky130_fd_sc_hd__dlygate4sd3_1
Xhold987 _7022_/Q VGND VGND VPWR VPWR _5611_/A sky130_fd_sc_hd__dlygate4sd3_1
Xhold976 _7019_/Q VGND VGND VPWR VPWR _5617_/A sky130_fd_sc_hd__dlygate4sd3_1
Xhold965 _7315_/Q VGND VGND VPWR VPWR _4528_/A sky130_fd_sc_hd__dlygate4sd3_1
XFILLER_103_546 VGND VGND VPWR VPWR sky130_fd_sc_hd__decap_3
XFILLER_76_408 VGND VGND VPWR VPWR sky130_fd_sc_hd__decap_3
XFILLER_88_246 VGND VGND VPWR VPWR sky130_fd_sc_hd__decap_3
X_6267_ _6366_/A VGND VGND VPWR VPWR _6267_/Y sky130_fd_sc_hd__inv_2
X_3479_ _7152_/Q _4334_/B1 _3478_/X VGND VGND VPWR VPWR _3482_/A sky130_fd_sc_hd__a21o_2
XFILLER_57_600 VGND VGND VPWR VPWR sky130_fd_sc_hd__decap_3
XFILLER_28_24 VGND VGND VPWR VPWR sky130_fd_sc_hd__decap_3
XFILLER_57_644 VGND VGND VPWR VPWR sky130_fd_sc_hd__decap_3
XFILLER_84_430 VGND VGND VPWR VPWR sky130_fd_sc_hd__decap_3
X_5149_ _5145_/A _4852_/A _5147_/X _5148_/X VGND VGND VPWR VPWR _5149_/Y sky130_fd_sc_hd__o211ai_2
XFILLER_28_79 VGND VGND VPWR VPWR sky130_fd_sc_hd__decap_3
XFILLER_56_165 VGND VGND VPWR VPWR sky130_fd_sc_hd__decap_3
XFILLER_57_688 VGND VGND VPWR VPWR sky130_fd_sc_hd__decap_3
XFILLER_84_463 VGND VGND VPWR VPWR sky130_fd_sc_hd__decap_3
XFILLER_71_113 VGND VGND VPWR VPWR sky130_fd_sc_hd__decap_3
XFILLER_72_636 VGND VGND VPWR VPWR sky130_fd_sc_hd__decap_3
XFILLER_44_12 VGND VGND VPWR VPWR sky130_fd_sc_hd__decap_3
XFILLER_71_135 VGND VGND VPWR VPWR sky130_fd_sc_hd__decap_3
XFILLER_72_669 VGND VGND VPWR VPWR sky130_fd_sc_hd__decap_3
XFILLER_44_67 VGND VGND VPWR VPWR sky130_fd_sc_hd__decap_3
XFILLER_12_224 VGND VGND VPWR VPWR sky130_fd_sc_hd__decap_3
XFILLER_40_533 VGND VGND VPWR VPWR sky130_fd_sc_hd__decap_3
XFILLER_12_268 VGND VGND VPWR VPWR sky130_fd_sc_hd__decap_3
XFILLER_4_412 VGND VGND VPWR VPWR sky130_fd_sc_hd__decap_3
XFILLER_60_99 VGND VGND VPWR VPWR sky130_fd_sc_hd__fill_1
XFILLER_106_340 VGND VGND VPWR VPWR sky130_fd_sc_hd__decap_3
XFILLER_109_60 VGND VGND VPWR VPWR sky130_fd_sc_hd__decap_3
XFILLER_4_445 VGND VGND VPWR VPWR sky130_fd_sc_hd__decap_3
XFILLER_5_39 VGND VGND VPWR VPWR sky130_fd_sc_hd__decap_3
XFILLER_109_93 VGND VGND VPWR VPWR sky130_fd_sc_hd__decap_3
XFILLER_69_75 VGND VGND VPWR VPWR sky130_fd_sc_hd__decap_3
XFILLER_0_651 VGND VGND VPWR VPWR sky130_fd_sc_hd__decap_3
XFILLER_0_673 VGND VGND VPWR VPWR sky130_fd_sc_hd__decap_3
XFILLER_10_9 VGND VGND VPWR VPWR sky130_fd_sc_hd__decap_3
XFILLER_48_622 VGND VGND VPWR VPWR sky130_fd_sc_hd__decap_3
XFILLER_87_290 VGND VGND VPWR VPWR sky130_fd_sc_hd__decap_3
XFILLER_94_238 VGND VGND VPWR VPWR sky130_fd_sc_hd__decap_3
XTAP_TAPCELL_ROW_89_1320 VGND VPWR sky130_fd_sc_hd__tapvpwrvgnd_1
XFILLER_47_143 VGND VGND VPWR VPWR sky130_fd_sc_hd__decap_3
XFILLER_48_666 VGND VGND VPWR VPWR sky130_fd_sc_hd__decap_3
XTAP_TAPCELL_ROW_46_801 VGND VPWR sky130_fd_sc_hd__tapvpwrvgnd_1
XFILLER_62_113 VGND VGND VPWR VPWR sky130_fd_sc_hd__decap_3
XFILLER_63_647 VGND VGND VPWR VPWR sky130_fd_sc_hd__decap_3
XFILLER_16_530 VGND VGND VPWR VPWR sky130_fd_sc_hd__fill_2
XFILLER_16_541 VGND VGND VPWR VPWR sky130_fd_sc_hd__decap_3
XFILLER_35_349 VGND VGND VPWR VPWR sky130_fd_sc_hd__decap_3
XFILLER_43_393 VGND VGND VPWR VPWR sky130_fd_sc_hd__decap_3
XFILLER_71_691 VGND VGND VPWR VPWR sky130_fd_sc_hd__fill_1
XFILLER_93_6 VGND VGND VPWR VPWR sky130_fd_sc_hd__decap_3
XFILLER_11_290 VGND VGND VPWR VPWR sky130_fd_sc_hd__fill_1
X_4520_ _7319_/Q _7287_/Q _4522_/S VGND VGND VPWR VPWR _7319_/D sky130_fd_sc_hd__mux2_2
XFILLER_116_126 VGND VGND VPWR VPWR sky130_fd_sc_hd__decap_3
X_4451_ _4451_/A _4451_/B VGND VGND VPWR VPWR _4765_/B sky130_fd_sc_hd__nor2_2
X_7170_ _7397_/CLK _7170_/D _6450_/Y VGND VGND VPWR VPWR _7170_/Q sky130_fd_sc_hd__dfrtp_2
X_3402_ _3385_/Y _3401_/X _3318_/B VGND VGND VPWR VPWR _3421_/C sky130_fd_sc_hd__a21oi_4
X_4382_ _4634_/D _4967_/B VGND VGND VPWR VPWR _4383_/C sky130_fd_sc_hd__nor2_2
XFILLER_98_533 VGND VGND VPWR VPWR sky130_fd_sc_hd__decap_3
XFILLER_100_505 VGND VGND VPWR VPWR sky130_fd_sc_hd__decap_3
XFILLER_105_18 VGND VGND VPWR VPWR sky130_fd_sc_hd__decap_3
XFILLER_112_365 VGND VGND VPWR VPWR sky130_fd_sc_hd__decap_3
XFILLER_85_205 VGND VGND VPWR VPWR sky130_fd_sc_hd__decap_3
XFILLER_85_216 VGND VGND VPWR VPWR sky130_fd_sc_hd__decap_3
XPHY_EDGE_ROW_7_Right_7 VGND VGND VPWR VPWR sky130_fd_sc_hd__decap_3
XFILLER_98_599 VGND VGND VPWR VPWR sky130_fd_sc_hd__fill_2
XFILLER_39_633 VGND VGND VPWR VPWR sky130_fd_sc_hd__fill_2
X_5003_ _5003_/A _5003_/B VGND VGND VPWR VPWR _5003_/X sky130_fd_sc_hd__or2_2
XFILLER_66_452 VGND VGND VPWR VPWR sky130_fd_sc_hd__decap_3
XFILLER_26_305 VGND VGND VPWR VPWR sky130_fd_sc_hd__decap_3
XFILLER_39_688 VGND VGND VPWR VPWR sky130_fd_sc_hd__decap_3
XFILLER_54_625 VGND VGND VPWR VPWR sky130_fd_sc_hd__decap_3
XFILLER_81_422 VGND VGND VPWR VPWR sky130_fd_sc_hd__decap_3
XFILLER_54_669 VGND VGND VPWR VPWR sky130_fd_sc_hd__decap_3
XFILLER_81_455 VGND VGND VPWR VPWR sky130_fd_sc_hd__decap_3
X_6954_ _6976_/CLK _6954_/D VGND VGND VPWR VPWR _6954_/Q sky130_fd_sc_hd__dfxtp_2
XFILLER_14_15 VGND VGND VPWR VPWR sky130_fd_sc_hd__decap_3
XFILLER_22_533 VGND VGND VPWR VPWR sky130_fd_sc_hd__decap_3
XFILLER_34_393 VGND VGND VPWR VPWR sky130_fd_sc_hd__decap_3
X_6885_ _7405_/CLK _6885_/D VGND VGND VPWR VPWR _6885_/Q sky130_fd_sc_hd__dfxtp_2
XTAP_TAPCELL_ROW_24_539 VGND VPWR sky130_fd_sc_hd__tapvpwrvgnd_1
XFILLER_14_59 VGND VGND VPWR VPWR sky130_fd_sc_hd__decap_3
XFILLER_61_190 VGND VGND VPWR VPWR sky130_fd_sc_hd__decap_3
XFILLER_108_616 VGND VGND VPWR VPWR sky130_fd_sc_hd__decap_3
XFILLER_30_14 VGND VGND VPWR VPWR sky130_fd_sc_hd__decap_3
X_4718_ _4718_/A0 _4716_/X _4837_/S VGND VGND VPWR VPWR _7278_/D sky130_fd_sc_hd__mux2_4
XFILLER_30_47 VGND VGND VPWR VPWR sky130_fd_sc_hd__decap_3
X_4649_ _4649_/A _4649_/B _4425_/C VGND VGND VPWR VPWR _4652_/A sky130_fd_sc_hd__nor3b_2
XFILLER_116_660 VGND VGND VPWR VPWR sky130_fd_sc_hd__fill_2
XFILLER_116_682 VGND VGND VPWR VPWR sky130_fd_sc_hd__fill_2
XFILLER_1_426 VGND VGND VPWR VPWR sky130_fd_sc_hd__decap_3
X_7368_ _7368_/CLK _7368_/D _6648_/Y VGND VGND VPWR VPWR _7368_/Q sky130_fd_sc_hd__dfrtp_2
Xhold740 _6795_/Q VGND VGND VPWR VPWR _6795_/D sky130_fd_sc_hd__dlygate4sd3_1
Xhold751 _6951_/Q VGND VGND VPWR VPWR _6951_/D sky130_fd_sc_hd__dlygate4sd3_1
Xhold762 _6826_/Q VGND VGND VPWR VPWR _6826_/D sky130_fd_sc_hd__dlygate4sd3_1
Xhold773 _6903_/Q VGND VGND VPWR VPWR _6903_/D sky130_fd_sc_hd__dlygate4sd3_1
XTAP_TAPCELL_ROW_73_1132 VGND VPWR sky130_fd_sc_hd__tapvpwrvgnd_1
XFILLER_115_181 VGND VGND VPWR VPWR sky130_fd_sc_hd__decap_3
XFILLER_39_12 VGND VGND VPWR VPWR sky130_fd_sc_hd__decap_3
XFILLER_89_533 VGND VGND VPWR VPWR sky130_fd_sc_hd__decap_3
X_7299_ _7363_/CLK _7299_/D _6579_/Y VGND VGND VPWR VPWR _7299_/Q sky130_fd_sc_hd__dfrtp_2
Xhold784 _6825_/Q VGND VGND VPWR VPWR _6825_/D sky130_fd_sc_hd__dlygate4sd3_1
Xhold795 _6855_/Q VGND VGND VPWR VPWR _6855_/D sky130_fd_sc_hd__dlygate4sd3_1
X_6319_ _6674_/A VGND VGND VPWR VPWR _6319_/Y sky130_fd_sc_hd__inv_2
XFILLER_103_376 VGND VGND VPWR VPWR sky130_fd_sc_hd__decap_3
XFILLER_49_419 VGND VGND VPWR VPWR sky130_fd_sc_hd__decap_3
XFILLER_29_154 VGND VGND VPWR VPWR sky130_fd_sc_hd__decap_3
XFILLER_69_290 VGND VGND VPWR VPWR sky130_fd_sc_hd__decap_3
XFILLER_29_165 VGND VGND VPWR VPWR sky130_fd_sc_hd__decap_3
XFILLER_72_411 VGND VGND VPWR VPWR sky130_fd_sc_hd__decap_3
XTAP_TAPCELL_ROW_4_297 VGND VPWR sky130_fd_sc_hd__tapvpwrvgnd_1
XFILLER_44_124 VGND VGND VPWR VPWR sky130_fd_sc_hd__decap_3
XFILLER_45_647 VGND VGND VPWR VPWR sky130_fd_sc_hd__decap_3
XFILLER_55_66 VGND VGND VPWR VPWR sky130_fd_sc_hd__decap_3
XFILLER_72_433 VGND VGND VPWR VPWR sky130_fd_sc_hd__decap_3
XFILLER_72_444 VGND VGND VPWR VPWR sky130_fd_sc_hd__decap_3
XFILLER_55_99 VGND VGND VPWR VPWR sky130_fd_sc_hd__fill_1
XFILLER_60_628 VGND VGND VPWR VPWR sky130_fd_sc_hd__decap_3
XTAP_TAPCELL_ROW_84_1261 VGND VPWR sky130_fd_sc_hd__tapvpwrvgnd_1
XFILLER_111_50 VGND VGND VPWR VPWR sky130_fd_sc_hd__decap_3
XFILLER_111_72 VGND VGND VPWR VPWR sky130_fd_sc_hd__decap_3
XFILLER_25_393 VGND VGND VPWR VPWR sky130_fd_sc_hd__decap_3
XFILLER_71_21 VGND VGND VPWR VPWR sky130_fd_sc_hd__decap_3
XFILLER_40_330 VGND VGND VPWR VPWR sky130_fd_sc_hd__decap_3
XFILLER_40_363 VGND VGND VPWR VPWR sky130_fd_sc_hd__fill_1
XFILLER_40_385 VGND VGND VPWR VPWR sky130_fd_sc_hd__fill_1
XFILLER_114_619 VGND VGND VPWR VPWR sky130_fd_sc_hd__decap_3
XFILLER_107_671 VGND VGND VPWR VPWR sky130_fd_sc_hd__fill_1
XFILLER_107_682 VGND VGND VPWR VPWR sky130_fd_sc_hd__decap_3
XFILLER_4_253 VGND VGND VPWR VPWR sky130_fd_sc_hd__fill_1
XTAP_TAPCELL_ROW_95_1390 VGND VPWR sky130_fd_sc_hd__tapvpwrvgnd_1
XFILLER_99_319 VGND VGND VPWR VPWR sky130_fd_sc_hd__decap_3
XFILLER_106_170 VGND VGND VPWR VPWR sky130_fd_sc_hd__fill_1
XFILLER_20_91 VGND VGND VPWR VPWR sky130_fd_sc_hd__fill_1
XFILLER_95_503 VGND VGND VPWR VPWR sky130_fd_sc_hd__fill_1
XFILLER_96_62 VGND VGND VPWR VPWR sky130_fd_sc_hd__decap_3
XFILLER_48_430 VGND VGND VPWR VPWR sky130_fd_sc_hd__decap_3
XFILLER_35_102 VGND VGND VPWR VPWR sky130_fd_sc_hd__decap_3
XFILLER_35_113 VGND VGND VPWR VPWR sky130_fd_sc_hd__decap_3
XFILLER_63_444 VGND VGND VPWR VPWR sky130_fd_sc_hd__decap_3
XFILLER_75_293 VGND VGND VPWR VPWR sky130_fd_sc_hd__fill_1
Xplace400 _4503_/S VGND VGND VPWR VPWR _4534_/S sky130_fd_sc_hd__buf_2
Xplace411 _4196_/A2 VGND VGND VPWR VPWR _4419_/B1 sky130_fd_sc_hd__buf_2
Xplace422 _3958_/S VGND VGND VPWR VPWR _3945_/S sky130_fd_sc_hd__buf_2
XFILLER_51_617 VGND VGND VPWR VPWR sky130_fd_sc_hd__decap_3
XFILLER_63_488 VGND VGND VPWR VPWR sky130_fd_sc_hd__fill_1
XFILLER_90_274 VGND VGND VPWR VPWR sky130_fd_sc_hd__decap_3
Xplace433 _3366_/X VGND VGND VPWR VPWR _4261_/B1 sky130_fd_sc_hd__buf_2
Xplace444 _4909_/A VGND VGND VPWR VPWR _5587_/B sky130_fd_sc_hd__buf_2
Xplace455 _6982_/Q VGND VGND VPWR VPWR _3561_/A sky130_fd_sc_hd__buf_2
XFILLER_44_691 VGND VGND VPWR VPWR sky130_fd_sc_hd__fill_1
XFILLER_50_149 VGND VGND VPWR VPWR sky130_fd_sc_hd__decap_3
XFILLER_91_3 VGND VGND VPWR VPWR sky130_fd_sc_hd__decap_3
X_6670_ _6670_/A VGND VGND VPWR VPWR _6670_/Y sky130_fd_sc_hd__inv_2
X_3882_ _6974_/Q _3882_/A2 _3884_/B1 _6969_/Q _3881_/X VGND VGND VPWR VPWR _3882_/X
+ sky130_fd_sc_hd__a221o_2
XTAP_TAPCELL_ROW_21_509 VGND VPWR sky130_fd_sc_hd__tapvpwrvgnd_1
XFILLER_31_374 VGND VGND VPWR VPWR sky130_fd_sc_hd__decap_3
XFILLER_31_396 VGND VGND VPWR VPWR sky130_fd_sc_hd__decap_3
X_5621_ _5621_/A VGND VGND VPWR VPWR _5622_/A sky130_fd_sc_hd__inv_2
X_4503_ _4503_/A0 _4569_/A _4503_/S VGND VGND VPWR VPWR _7328_/D sky130_fd_sc_hd__mux2_2
XFILLER_6_71 VGND VGND VPWR VPWR sky130_fd_sc_hd__decap_3
X_7222_ clkload3/A _7222_/D _6502_/Y VGND VGND VPWR VPWR _7222_/Q sky130_fd_sc_hd__dfrtp_2
X_4434_ _7111_/Q _4434_/A2 _4434_/B1 _7143_/Q _4433_/X VGND VGND VPWR VPWR _4434_/X
+ sky130_fd_sc_hd__a221o_2
XFILLER_113_641 VGND VGND VPWR VPWR sky130_fd_sc_hd__decap_3
X_7153_ _7352_/CLK _7153_/D _6433_/Y VGND VGND VPWR VPWR _7153_/Q sky130_fd_sc_hd__dfrtp_2
X_4365_ _4365_/A _4365_/B _4365_/C VGND VGND VPWR VPWR _4365_/X sky130_fd_sc_hd__and3_2
X_7084_ _7234_/CLK _7084_/D _6364_/Y VGND VGND VPWR VPWR _7084_/Q sky130_fd_sc_hd__dfrtp_2
X_3316_ _3353_/A _4697_/A VGND VGND VPWR VPWR _3332_/B sky130_fd_sc_hd__nor2b_2
XFILLER_98_352 VGND VGND VPWR VPWR sky130_fd_sc_hd__decap_3
XFILLER_112_162 VGND VGND VPWR VPWR sky130_fd_sc_hd__decap_3
XFILLER_112_195 VGND VGND VPWR VPWR sky130_fd_sc_hd__fill_1
XFILLER_86_536 VGND VGND VPWR VPWR sky130_fd_sc_hd__decap_3
X_4296_ _4292_/A _3591_/Y _4295_/X VGND VGND VPWR VPWR _4297_/B sky130_fd_sc_hd__a21oi_2
XFILLER_98_385 VGND VGND VPWR VPWR sky130_fd_sc_hd__decap_3
XFILLER_100_368 VGND VGND VPWR VPWR sky130_fd_sc_hd__decap_3
XFILLER_39_452 VGND VGND VPWR VPWR sky130_fd_sc_hd__decap_3
XFILLER_27_614 VGND VGND VPWR VPWR sky130_fd_sc_hd__fill_2
XFILLER_27_636 VGND VGND VPWR VPWR sky130_fd_sc_hd__fill_2
XFILLER_73_219 VGND VGND VPWR VPWR sky130_fd_sc_hd__decap_3
XFILLER_27_658 VGND VGND VPWR VPWR sky130_fd_sc_hd__fill_2
XFILLER_54_444 VGND VGND VPWR VPWR sky130_fd_sc_hd__decap_3
XTAP_TAPCELL_ROW_1_267 VGND VPWR sky130_fd_sc_hd__tapvpwrvgnd_1
XTAP_TAPCELL_ROW_107_1537 VGND VPWR sky130_fd_sc_hd__tapvpwrvgnd_1
XFILLER_26_179 VGND VGND VPWR VPWR sky130_fd_sc_hd__fill_1
XFILLER_81_252 VGND VGND VPWR VPWR sky130_fd_sc_hd__decap_3
XFILLER_41_116 VGND VGND VPWR VPWR sky130_fd_sc_hd__decap_3
X_6937_ _7406_/CLK _6937_/D VGND VGND VPWR VPWR _6937_/Q sky130_fd_sc_hd__dfxtp_2
XTAP_TAPCELL_ROW_37_697 VGND VPWR sky130_fd_sc_hd__tapvpwrvgnd_1
XFILLER_22_330 VGND VGND VPWR VPWR sky130_fd_sc_hd__decap_3
XFILLER_22_352 VGND VGND VPWR VPWR sky130_fd_sc_hd__fill_2
X_6868_ _7383_/CLK _6868_/D VGND VGND VPWR VPWR _6868_/Q sky130_fd_sc_hd__dfxtp_2
XFILLER_10_503 VGND VGND VPWR VPWR sky130_fd_sc_hd__fill_1
XFILLER_22_363 VGND VGND VPWR VPWR sky130_fd_sc_hd__fill_1
XFILLER_50_672 VGND VGND VPWR VPWR sky130_fd_sc_hd__decap_3
XFILLER_41_35 VGND VGND VPWR VPWR sky130_fd_sc_hd__decap_3
XFILLER_41_57 VGND VGND VPWR VPWR sky130_fd_sc_hd__decap_3
X_6799_ _7406_/CLK _6799_/D VGND VGND VPWR VPWR _6799_/Q sky130_fd_sc_hd__dfxtp_2
XFILLER_108_413 VGND VGND VPWR VPWR sky130_fd_sc_hd__fill_1
XTAP_TAPCELL_ROW_9_356 VGND VPWR sky130_fd_sc_hd__tapvpwrvgnd_1
XFILLER_104_663 VGND VGND VPWR VPWR sky130_fd_sc_hd__decap_3
XFILLER_77_514 VGND VGND VPWR VPWR sky130_fd_sc_hd__decap_3
XFILLER_89_352 VGND VGND VPWR VPWR sky130_fd_sc_hd__decap_3
Xhold592 _6884_/Q VGND VGND VPWR VPWR _6884_/D sky130_fd_sc_hd__dlygate4sd3_1
XFILLER_106_50 VGND VGND VPWR VPWR sky130_fd_sc_hd__decap_3
XFILLER_2_29 VGND VGND VPWR VPWR sky130_fd_sc_hd__decap_3
XFILLER_77_547 VGND VGND VPWR VPWR sky130_fd_sc_hd__decap_3
XFILLER_89_396 VGND VGND VPWR VPWR sky130_fd_sc_hd__decap_3
XFILLER_103_195 VGND VGND VPWR VPWR sky130_fd_sc_hd__decap_3
XFILLER_106_83 VGND VGND VPWR VPWR sky130_fd_sc_hd__fill_1
XFILLER_66_21 VGND VGND VPWR VPWR sky130_fd_sc_hd__decap_3
XFILLER_66_32 VGND VGND VPWR VPWR sky130_fd_sc_hd__decap_3
XFILLER_66_54 VGND VGND VPWR VPWR sky130_fd_sc_hd__decap_3
XFILLER_18_625 VGND VGND VPWR VPWR sky130_fd_sc_hd__fill_1
XFILLER_45_411 VGND VGND VPWR VPWR sky130_fd_sc_hd__decap_3
XFILLER_57_260 VGND VGND VPWR VPWR sky130_fd_sc_hd__decap_3
XFILLER_92_528 VGND VGND VPWR VPWR sky130_fd_sc_hd__decap_3
XFILLER_92_539 VGND VGND VPWR VPWR sky130_fd_sc_hd__fill_1
XFILLER_17_113 VGND VGND VPWR VPWR sky130_fd_sc_hd__fill_1
XFILLER_18_669 VGND VGND VPWR VPWR sky130_fd_sc_hd__decap_3
XFILLER_45_444 VGND VGND VPWR VPWR sky130_fd_sc_hd__decap_3
XFILLER_57_293 VGND VGND VPWR VPWR sky130_fd_sc_hd__decap_3
XFILLER_66_98 VGND VGND VPWR VPWR sky130_fd_sc_hd__fill_2
XFILLER_17_157 VGND VGND VPWR VPWR sky130_fd_sc_hd__decap_3
XFILLER_33_617 VGND VGND VPWR VPWR sky130_fd_sc_hd__decap_3
XFILLER_32_116 VGND VGND VPWR VPWR sky130_fd_sc_hd__decap_3
XFILLER_82_53 VGND VGND VPWR VPWR sky130_fd_sc_hd__decap_3
XFILLER_9_334 VGND VGND VPWR VPWR sky130_fd_sc_hd__fill_2
XFILLER_40_193 VGND VGND VPWR VPWR sky130_fd_sc_hd__decap_3
XFILLER_114_416 VGND VGND VPWR VPWR sky130_fd_sc_hd__decap_3
XFILLER_56_6 VGND VGND VPWR VPWR sky130_fd_sc_hd__decap_3
XFILLER_5_573 VGND VGND VPWR VPWR sky130_fd_sc_hd__decap_3
XFILLER_99_116 VGND VGND VPWR VPWR sky130_fd_sc_hd__decap_3
XFILLER_99_105 VGND VGND VPWR VPWR sky130_fd_sc_hd__decap_3
X_4150_ _7234_/Q _3318_/B _4394_/B _7362_/Q VGND VGND VPWR VPWR _4150_/X sky130_fd_sc_hd__a22o_2
XFILLER_110_622 VGND VGND VPWR VPWR sky130_fd_sc_hd__decap_3
XFILLER_95_300 VGND VGND VPWR VPWR sky130_fd_sc_hd__decap_3
XFILLER_110_666 VGND VGND VPWR VPWR sky130_fd_sc_hd__decap_3
X_4081_ _4451_/A _4451_/B VGND VGND VPWR VPWR _4081_/X sky130_fd_sc_hd__or2b_2
XFILLER_83_539 VGND VGND VPWR VPWR sky130_fd_sc_hd__fill_2
XFILLER_48_282 VGND VGND VPWR VPWR sky130_fd_sc_hd__decap_3
XFILLER_36_466 VGND VGND VPWR VPWR sky130_fd_sc_hd__fill_1
XFILLER_63_252 VGND VGND VPWR VPWR sky130_fd_sc_hd__decap_3
XFILLER_91_561 VGND VGND VPWR VPWR sky130_fd_sc_hd__decap_3
XFILLER_23_105 VGND VGND VPWR VPWR sky130_fd_sc_hd__decap_3
XFILLER_23_116 VGND VGND VPWR VPWR sky130_fd_sc_hd__decap_3
XFILLER_51_447 VGND VGND VPWR VPWR sky130_fd_sc_hd__fill_1
XFILLER_63_296 VGND VGND VPWR VPWR sky130_fd_sc_hd__decap_3
Xplace263 _5658_/D VGND VGND VPWR VPWR _5117_/B sky130_fd_sc_hd__buf_2
X_4983_ _4983_/A _4983_/B _4983_/C VGND VGND VPWR VPWR _4983_/X sky130_fd_sc_hd__and3_2
Xplace296 _3913_/A2 VGND VGND VPWR VPWR _3889_/A2 sky130_fd_sc_hd__buf_2
Xplace285 _3889_/B1 VGND VGND VPWR VPWR _3913_/B1 sky130_fd_sc_hd__buf_2
Xplace274 _3902_/A2 VGND VGND VPWR VPWR _3768_/A2 sky130_fd_sc_hd__buf_2
X_6722_ clkload2/A _6722_/D VGND VGND VPWR VPWR _6722_/Q sky130_fd_sc_hd__dfxtp_2
XTAP_TAPCELL_ROW_34_656 VGND VPWR sky130_fd_sc_hd__tapvpwrvgnd_1
X_6653_ _6683_/A VGND VGND VPWR VPWR _6653_/Y sky130_fd_sc_hd__inv_2
XTAP_TAPCELL_ROW_62_998 VGND VPWR sky130_fd_sc_hd__tapvpwrvgnd_1
XTAP_TAPCELL_ROW_102_1478 VGND VPWR sky130_fd_sc_hd__tapvpwrvgnd_1
XFILLER_31_193 VGND VGND VPWR VPWR sky130_fd_sc_hd__decap_3
X_6584_ _6584_/A VGND VGND VPWR VPWR _6584_/Y sky130_fd_sc_hd__inv_2
X_3796_ _6726_/Q _3879_/A2 _3882_/A2 _6976_/Q _3795_/X VGND VGND VPWR VPWR _3796_/X
+ sky130_fd_sc_hd__a221o_2
XFILLER_11_27 VGND VGND VPWR VPWR sky130_fd_sc_hd__decap_3
XFILLER_105_405 VGND VGND VPWR VPWR sky130_fd_sc_hd__decap_3
XFILLER_105_449 VGND VGND VPWR VPWR sky130_fd_sc_hd__decap_3
X_7205_ _7334_/CLK _7205_/D _6485_/Y VGND VGND VPWR VPWR _7205_/Q sky130_fd_sc_hd__dfrtp_2
X_4417_ _7304_/Q _4417_/A2 _4434_/A2 _7112_/Q _4416_/X VGND VGND VPWR VPWR _4417_/X
+ sky130_fd_sc_hd__a221o_2
XFILLER_101_600 VGND VGND VPWR VPWR sky130_fd_sc_hd__decap_3
XFILLER_59_503 VGND VGND VPWR VPWR sky130_fd_sc_hd__fill_1
XTAP_TAPCELL_ROW_6_326 VGND VPWR sky130_fd_sc_hd__tapvpwrvgnd_1
XFILLER_99_650 VGND VGND VPWR VPWR sky130_fd_sc_hd__decap_3
XFILLER_100_110 VGND VGND VPWR VPWR sky130_fd_sc_hd__decap_3
X_7136_ _7364_/CLK _7136_/D _6416_/Y VGND VGND VPWR VPWR _7136_/Q sky130_fd_sc_hd__dfrtp_2
X_4348_ _7161_/Q _3366_/X _4348_/B1 _7129_/Q _4347_/X VGND VGND VPWR VPWR _4348_/X
+ sky130_fd_sc_hd__a221o_2
XFILLER_101_644 VGND VGND VPWR VPWR sky130_fd_sc_hd__decap_3
XFILLER_59_569 VGND VGND VPWR VPWR sky130_fd_sc_hd__decap_3
XFILLER_86_355 VGND VGND VPWR VPWR sky130_fd_sc_hd__decap_3
X_7067_ clkload7/A _7067_/D _6347_/Y VGND VGND VPWR VPWR _7067_/Q sky130_fd_sc_hd__dfrtp_2
X_4279_ _7318_/Q _3977_/S _4303_/B1 _7126_/Q VGND VGND VPWR VPWR _4279_/X sky130_fd_sc_hd__a22o_2
XFILLER_101_688 VGND VGND VPWR VPWR sky130_fd_sc_hd__decap_3
XFILLER_86_377 VGND VGND VPWR VPWR sky130_fd_sc_hd__fill_1
XFILLER_36_24 VGND VGND VPWR VPWR sky130_fd_sc_hd__fill_1
XFILLER_39_293 VGND VGND VPWR VPWR sky130_fd_sc_hd__decap_3
XFILLER_54_230 VGND VGND VPWR VPWR sky130_fd_sc_hd__decap_3
XFILLER_36_57 VGND VGND VPWR VPWR sky130_fd_sc_hd__decap_3
XFILLER_36_79 VGND VGND VPWR VPWR sky130_fd_sc_hd__decap_3
XTAP_TAPCELL_ROW_68_1064 VGND VPWR sky130_fd_sc_hd__tapvpwrvgnd_1
XFILLER_27_499 VGND VGND VPWR VPWR sky130_fd_sc_hd__decap_3
XFILLER_54_296 VGND VGND VPWR VPWR sky130_fd_sc_hd__decap_3
XFILLER_14_149 VGND VGND VPWR VPWR sky130_fd_sc_hd__decap_3
XFILLER_42_469 VGND VGND VPWR VPWR sky130_fd_sc_hd__decap_3
XFILLER_52_23 VGND VGND VPWR VPWR sky130_fd_sc_hd__decap_3
XTAP_TAPCELL_ROW_81_1220 VGND VPWR sky130_fd_sc_hd__tapvpwrvgnd_1
XFILLER_10_344 VGND VGND VPWR VPWR sky130_fd_sc_hd__decap_3
XFILLER_50_491 VGND VGND VPWR VPWR sky130_fd_sc_hd__fill_1
XFILLER_6_304 VGND VGND VPWR VPWR sky130_fd_sc_hd__decap_3
XFILLER_6_326 VGND VGND VPWR VPWR sky130_fd_sc_hd__decap_3
XFILLER_108_221 VGND VGND VPWR VPWR sky130_fd_sc_hd__decap_3
XFILLER_6_348 VGND VGND VPWR VPWR sky130_fd_sc_hd__decap_3
XFILLER_108_298 VGND VGND VPWR VPWR sky130_fd_sc_hd__decap_3
XTAP_TAPCELL_ROW_92_1360 VGND VPWR sky130_fd_sc_hd__tapvpwrvgnd_1
XFILLER_104_471 VGND VGND VPWR VPWR sky130_fd_sc_hd__decap_3
XFILLER_104_493 VGND VGND VPWR VPWR sky130_fd_sc_hd__decap_3
XFILLER_2_598 VGND VGND VPWR VPWR sky130_fd_sc_hd__decap_3
XFILLER_89_182 VGND VGND VPWR VPWR sky130_fd_sc_hd__decap_3
XFILLER_92_347 VGND VGND VPWR VPWR sky130_fd_sc_hd__fill_1
XFILLER_18_466 VGND VGND VPWR VPWR sky130_fd_sc_hd__fill_1
XFILLER_73_572 VGND VGND VPWR VPWR sky130_fd_sc_hd__decap_3
XFILLER_93_63 VGND VGND VPWR VPWR sky130_fd_sc_hd__decap_3
XFILLER_45_296 VGND VGND VPWR VPWR sky130_fd_sc_hd__decap_3
XFILLER_73_594 VGND VGND VPWR VPWR sky130_fd_sc_hd__decap_3
XFILLER_60_233 VGND VGND VPWR VPWR sky130_fd_sc_hd__decap_3
XFILLER_14_683 VGND VGND VPWR VPWR sky130_fd_sc_hd__fill_1
XFILLER_20_108 VGND VGND VPWR VPWR sky130_fd_sc_hd__decap_3
XFILLER_60_277 VGND VGND VPWR VPWR sky130_fd_sc_hd__fill_2
XTAP_TAPCELL_ROW_31_626 VGND VPWR sky130_fd_sc_hd__tapvpwrvgnd_1
XFILLER_13_193 VGND VGND VPWR VPWR sky130_fd_sc_hd__decap_3
XFILLER_60_299 VGND VGND VPWR VPWR sky130_fd_sc_hd__fill_1
X_3650_ _3991_/B VGND VGND VPWR VPWR _3665_/A sky130_fd_sc_hd__inv_2
XFILLER_9_175 VGND VGND VPWR VPWR sky130_fd_sc_hd__fill_1
X_3581_ _7156_/Q _4334_/B1 _3579_/X _3580_/X VGND VGND VPWR VPWR _3583_/B sky130_fd_sc_hd__a211o_2
XTAP_TAPCELL_ROW_11_383 VGND VPWR sky130_fd_sc_hd__tapvpwrvgnd_1
XFILLER_54_3 VGND VGND VPWR VPWR sky130_fd_sc_hd__decap_3
XFILLER_114_224 VGND VGND VPWR VPWR sky130_fd_sc_hd__decap_3
XFILLER_5_381 VGND VGND VPWR VPWR sky130_fd_sc_hd__decap_3
X_5251_ _5251_/A0 _4899_/X _5262_/S VGND VGND VPWR VPWR _7204_/D sky130_fd_sc_hd__mux2_2
XFILLER_114_268 VGND VGND VPWR VPWR sky130_fd_sc_hd__decap_3
X_4202_ _4202_/A VGND VGND VPWR VPWR _4203_/C sky130_fd_sc_hd__inv_2
XFILLER_87_119 VGND VGND VPWR VPWR sky130_fd_sc_hd__decap_3
XFILLER_96_620 VGND VGND VPWR VPWR sky130_fd_sc_hd__decap_3
X_5182_ _5182_/A _5182_/B VGND VGND VPWR VPWR _7237_/D sky130_fd_sc_hd__and2_2
XFILLER_3_72 VGND VGND VPWR VPWR sky130_fd_sc_hd__decap_3
XFILLER_68_355 VGND VGND VPWR VPWR sky130_fd_sc_hd__decap_3
XFILLER_95_141 VGND VGND VPWR VPWR sky130_fd_sc_hd__decap_3
X_4133_ _7363_/Q _4394_/B _4436_/B1 _7171_/Q VGND VGND VPWR VPWR _4133_/X sky130_fd_sc_hd__a22o_2
XFILLER_110_463 VGND VGND VPWR VPWR sky130_fd_sc_hd__decap_3
XFILLER_113_18 VGND VGND VPWR VPWR sky130_fd_sc_hd__decap_3
XFILLER_68_399 VGND VGND VPWR VPWR sky130_fd_sc_hd__decap_3
XFILLER_83_314 VGND VGND VPWR VPWR sky130_fd_sc_hd__decap_3
XFILLER_96_675 VGND VGND VPWR VPWR sky130_fd_sc_hd__decap_3
X_4064_ _7372_/Q _4435_/B1 _4837_/S _7308_/Q _4063_/X VGND VGND VPWR VPWR _4064_/X
+ sky130_fd_sc_hd__a221o_2
XTAP_TAPCELL_ROW_39_715 VGND VPWR sky130_fd_sc_hd__tapvpwrvgnd_1
XFILLER_83_347 VGND VGND VPWR VPWR sky130_fd_sc_hd__fill_1
XFILLER_36_230 VGND VGND VPWR VPWR sky130_fd_sc_hd__decap_3
XFILLER_51_200 VGND VGND VPWR VPWR sky130_fd_sc_hd__decap_3
XTAP_TAPCELL_ROW_19_483 VGND VPWR sky130_fd_sc_hd__tapvpwrvgnd_1
XFILLER_24_469 VGND VGND VPWR VPWR sky130_fd_sc_hd__decap_3
XFILLER_91_391 VGND VGND VPWR VPWR sky130_fd_sc_hd__fill_1
XFILLER_11_108 VGND VGND VPWR VPWR sky130_fd_sc_hd__decap_3
XFILLER_11_119 VGND VGND VPWR VPWR sky130_fd_sc_hd__decap_3
X_6705_ _7406_/CLK _6705_/D VGND VGND VPWR VPWR _6705_/Q sky130_fd_sc_hd__dfxtp_2
XFILLER_22_15 VGND VGND VPWR VPWR sky130_fd_sc_hd__decap_3
X_4897_ _4896_/A _4896_/B _4896_/Y _5570_/A2 VGND VGND VPWR VPWR _4897_/X sky130_fd_sc_hd__o211a_2
X_3917_ _6689_/Q _5660_/B _3917_/B1 _6867_/Q VGND VGND VPWR VPWR _3917_/X sky130_fd_sc_hd__a22o_2
XFILLER_20_653 VGND VGND VPWR VPWR sky130_fd_sc_hd__decap_3
XFILLER_22_48 VGND VGND VPWR VPWR sky130_fd_sc_hd__fill_2
X_6636_ _6637_/A VGND VGND VPWR VPWR _6636_/Y sky130_fd_sc_hd__inv_2
X_3848_ _6907_/Q _3879_/A2 _3889_/B1 _6851_/Q VGND VGND VPWR VPWR _3848_/X sky130_fd_sc_hd__a22o_2
X_6567_ _6567_/A VGND VGND VPWR VPWR _6567_/Y sky130_fd_sc_hd__inv_2
X_3779_ _6794_/Q _3907_/A2 _5660_/B _6704_/Q _3778_/X VGND VGND VPWR VPWR _3779_/X
+ sky130_fd_sc_hd__a221o_2
XFILLER_105_202 VGND VGND VPWR VPWR sky130_fd_sc_hd__fill_1
XTAP_TAPCELL_ROW_115_1636 VGND VPWR sky130_fd_sc_hd__tapvpwrvgnd_1
X_6498_ _6635_/A VGND VGND VPWR VPWR _6498_/Y sky130_fd_sc_hd__inv_2
XFILLER_105_246 VGND VGND VPWR VPWR sky130_fd_sc_hd__decap_3
XFILLER_59_300 VGND VGND VPWR VPWR sky130_fd_sc_hd__decap_3
XFILLER_78_119 VGND VGND VPWR VPWR sky130_fd_sc_hd__decap_3
XFILLER_87_620 VGND VGND VPWR VPWR sky130_fd_sc_hd__decap_3
Xoutput494 _5658_/C VGND VGND VPWR VPWR alu_result_out[9] sky130_fd_sc_hd__clkdlybuf4s25_1
Xoutput483 _5663_/A VGND VGND VPWR VPWR alu_result_out[28] sky130_fd_sc_hd__clkdlybuf4s25_1
Xoutput472 _5657_/C VGND VGND VPWR VPWR alu_result_out[18] sky130_fd_sc_hd__clkdlybuf4s25_1
XFILLER_101_441 VGND VGND VPWR VPWR sky130_fd_sc_hd__decap_3
XFILLER_47_12 VGND VGND VPWR VPWR sky130_fd_sc_hd__decap_3
XFILLER_59_333 VGND VGND VPWR VPWR sky130_fd_sc_hd__decap_3
XFILLER_87_653 VGND VGND VPWR VPWR sky130_fd_sc_hd__decap_3
X_7119_ _7312_/CLK _7119_/D _6399_/Y VGND VGND VPWR VPWR _7119_/Q sky130_fd_sc_hd__dfrtp_2
XFILLER_101_463 VGND VGND VPWR VPWR sky130_fd_sc_hd__decap_3
XFILLER_47_89 VGND VGND VPWR VPWR sky130_fd_sc_hd__fill_2
XFILLER_59_399 VGND VGND VPWR VPWR sky130_fd_sc_hd__decap_3
XFILLER_74_336 VGND VGND VPWR VPWR sky130_fd_sc_hd__decap_3
XFILLER_27_252 VGND VGND VPWR VPWR sky130_fd_sc_hd__decap_3
XFILLER_55_561 VGND VGND VPWR VPWR sky130_fd_sc_hd__fill_1
XFILLER_27_263 VGND VGND VPWR VPWR sky130_fd_sc_hd__decap_3
XFILLER_27_296 VGND VGND VPWR VPWR sky130_fd_sc_hd__decap_3
XFILLER_42_200 VGND VGND VPWR VPWR sky130_fd_sc_hd__decap_3
XFILLER_55_594 VGND VGND VPWR VPWR sky130_fd_sc_hd__decap_3
XFILLER_63_11 VGND VGND VPWR VPWR sky130_fd_sc_hd__decap_3
XFILLER_63_22 VGND VGND VPWR VPWR sky130_fd_sc_hd__decap_3
XFILLER_103_95 VGND VGND VPWR VPWR sky130_fd_sc_hd__decap_3
XFILLER_15_447 VGND VGND VPWR VPWR sky130_fd_sc_hd__fill_1
XFILLER_15_458 VGND VGND VPWR VPWR sky130_fd_sc_hd__decap_3
XFILLER_42_222 VGND VGND VPWR VPWR sky130_fd_sc_hd__decap_3
XFILLER_63_44 VGND VGND VPWR VPWR sky130_fd_sc_hd__decap_3
XFILLER_70_542 VGND VGND VPWR VPWR sky130_fd_sc_hd__fill_2
XFILLER_30_406 VGND VGND VPWR VPWR sky130_fd_sc_hd__decap_3
XFILLER_23_480 VGND VGND VPWR VPWR sky130_fd_sc_hd__decap_3
XFILLER_8_17 VGND VGND VPWR VPWR sky130_fd_sc_hd__decap_3
XFILLER_10_130 VGND VGND VPWR VPWR sky130_fd_sc_hd__decap_3
XFILLER_10_141 VGND VGND VPWR VPWR sky130_fd_sc_hd__fill_1
XFILLER_11_664 VGND VGND VPWR VPWR sky130_fd_sc_hd__decap_3
XFILLER_7_613 VGND VGND VPWR VPWR sky130_fd_sc_hd__decap_3
XFILLER_6_112 VGND VGND VPWR VPWR sky130_fd_sc_hd__decap_3
XFILLER_7_657 VGND VGND VPWR VPWR sky130_fd_sc_hd__decap_3
XFILLER_109_585 VGND VGND VPWR VPWR sky130_fd_sc_hd__decap_3
XFILLER_6_156 VGND VGND VPWR VPWR sky130_fd_sc_hd__fill_2
XFILLER_7_679 VGND VGND VPWR VPWR sky130_fd_sc_hd__decap_3
Xwire577 _6652_/A VGND VGND VPWR VPWR _6280_/A sky130_fd_sc_hd__buf_2
XFILLER_40_9 VGND VGND VPWR VPWR sky130_fd_sc_hd__decap_3
XFILLER_69_108 VGND VGND VPWR VPWR sky130_fd_sc_hd__decap_3
XFILLER_88_63 VGND VGND VPWR VPWR sky130_fd_sc_hd__decap_3
XFILLER_111_205 VGND VGND VPWR VPWR sky130_fd_sc_hd__decap_3
XFILLER_88_85 VGND VGND VPWR VPWR sky130_fd_sc_hd__decap_3
XFILLER_104_290 VGND VGND VPWR VPWR sky130_fd_sc_hd__decap_3
XFILLER_2_395 VGND VGND VPWR VPWR sky130_fd_sc_hd__decap_3
XFILLER_78_631 VGND VGND VPWR VPWR sky130_fd_sc_hd__decap_3
XFILLER_77_141 VGND VGND VPWR VPWR sky130_fd_sc_hd__decap_3
XFILLER_77_163 VGND VGND VPWR VPWR sky130_fd_sc_hd__fill_2
XFILLER_78_675 VGND VGND VPWR VPWR sky130_fd_sc_hd__decap_3
XFILLER_92_100 VGND VGND VPWR VPWR sky130_fd_sc_hd__decap_3
XFILLER_93_623 VGND VGND VPWR VPWR sky130_fd_sc_hd__decap_3
XFILLER_65_325 VGND VGND VPWR VPWR sky130_fd_sc_hd__decap_3
XFILLER_92_133 VGND VGND VPWR VPWR sky130_fd_sc_hd__decap_3
XFILLER_93_656 VGND VGND VPWR VPWR sky130_fd_sc_hd__decap_3
XFILLER_46_561 VGND VGND VPWR VPWR sky130_fd_sc_hd__decap_3
XFILLER_65_369 VGND VGND VPWR VPWR sky130_fd_sc_hd__decap_3
XFILLER_18_285 VGND VGND VPWR VPWR sky130_fd_sc_hd__fill_2
XFILLER_18_296 VGND VGND VPWR VPWR sky130_fd_sc_hd__fill_2
XFILLER_61_542 VGND VGND VPWR VPWR sky130_fd_sc_hd__decap_3
XFILLER_61_553 VGND VGND VPWR VPWR sky130_fd_sc_hd__decap_3
XFILLER_73_391 VGND VGND VPWR VPWR sky130_fd_sc_hd__fill_1
X_4820_ _4836_/S _5634_/B VGND VGND VPWR VPWR _5010_/A sky130_fd_sc_hd__nand2_2
XTAP_TAPCELL_ROW_16_442 VGND VPWR sky130_fd_sc_hd__tapvpwrvgnd_1
XFILLER_33_266 VGND VGND VPWR VPWR sky130_fd_sc_hd__fill_1
XFILLER_61_564 VGND VGND VPWR VPWR sky130_fd_sc_hd__decap_3
XTAP_TAPCELL_ROW_44_784 VGND VPWR sky130_fd_sc_hd__tapvpwrvgnd_1
X_4751_ _4751_/A _4751_/B VGND VGND VPWR VPWR _4751_/Y sky130_fd_sc_hd__nand2_2
X_4682_ _4928_/B _4682_/B _4960_/B VGND VGND VPWR VPWR _4943_/A sky130_fd_sc_hd__and3b_2
X_3702_ hold982/X _3757_/S _3701_/X VGND VGND VPWR VPWR _7401_/D sky130_fd_sc_hd__o21a_2
X_6421_ _6522_/A VGND VGND VPWR VPWR _6421_/Y sky130_fd_sc_hd__inv_2
X_3633_ _3636_/A _5114_/A _3635_/B _3630_/A VGND VGND VPWR VPWR _3633_/Y sky130_fd_sc_hd__a22oi_2
XFILLER_108_18 VGND VGND VPWR VPWR sky130_fd_sc_hd__decap_3
XFILLER_108_29 VGND VGND VPWR VPWR sky130_fd_sc_hd__decap_3
XFILLER_115_511 VGND VGND VPWR VPWR sky130_fd_sc_hd__decap_3
X_6352_ _6388_/A VGND VGND VPWR VPWR _6352_/Y sky130_fd_sc_hd__inv_2
X_3564_ _5118_/A _5362_/C VGND VGND VPWR VPWR _3564_/X sky130_fd_sc_hd__and2_2
XFILLER_115_544 VGND VGND VPWR VPWR sky130_fd_sc_hd__decap_3
X_6283_ _6285_/A VGND VGND VPWR VPWR _6283_/Y sky130_fd_sc_hd__inv_2
X_3495_ _7028_/Q _4510_/S _3494_/X VGND VGND VPWR VPWR _3495_/X sky130_fd_sc_hd__a21o_2
XFILLER_115_588 VGND VGND VPWR VPWR sky130_fd_sc_hd__decap_3
XFILLER_69_620 VGND VGND VPWR VPWR sky130_fd_sc_hd__decap_3
XFILLER_88_439 VGND VGND VPWR VPWR sky130_fd_sc_hd__decap_3
X_5234_ _5234_/A0 _4734_/X _5245_/S VGND VGND VPWR VPWR _7213_/D sky130_fd_sc_hd__mux2_2
XFILLER_68_130 VGND VGND VPWR VPWR sky130_fd_sc_hd__decap_3
XFILLER_69_653 VGND VGND VPWR VPWR sky130_fd_sc_hd__decap_3
X_5165_ _5165_/A _5182_/B VGND VGND VPWR VPWR _7245_/D sky130_fd_sc_hd__and2_2
XTAP_TAPCELL_ROW_110_1566 VGND VPWR sky130_fd_sc_hd__tapvpwrvgnd_1
XFILLER_68_141 VGND VGND VPWR VPWR sky130_fd_sc_hd__decap_3
XFILLER_68_152 VGND VGND VPWR VPWR sky130_fd_sc_hd__decap_3
X_4116_ _7076_/Q _4265_/B VGND VGND VPWR VPWR _4117_/C sky130_fd_sc_hd__or2_2
XTAP_TAPCELL_ROW_110_1577 VGND VPWR sky130_fd_sc_hd__tapvpwrvgnd_1
XFILLER_110_271 VGND VGND VPWR VPWR sky130_fd_sc_hd__decap_3
XFILLER_83_111 VGND VGND VPWR VPWR sky130_fd_sc_hd__fill_1
XFILLER_83_122 VGND VGND VPWR VPWR sky130_fd_sc_hd__decap_3
XFILLER_84_634 VGND VGND VPWR VPWR sky130_fd_sc_hd__decap_3
XFILLER_84_645 VGND VGND VPWR VPWR sky130_fd_sc_hd__decap_3
XFILLER_96_483 VGND VGND VPWR VPWR sky130_fd_sc_hd__decap_3
XFILLER_17_15 VGND VGND VPWR VPWR sky130_fd_sc_hd__decap_3
XFILLER_83_155 VGND VGND VPWR VPWR sky130_fd_sc_hd__fill_2
XFILLER_84_678 VGND VGND VPWR VPWR sky130_fd_sc_hd__decap_3
X_4047_ _7245_/Q _4433_/B _4437_/A2 _7027_/Q _4046_/X VGND VGND VPWR VPWR _4047_/X
+ sky130_fd_sc_hd__a221o_2
XFILLER_24_200 VGND VGND VPWR VPWR sky130_fd_sc_hd__fill_1
XFILLER_24_233 VGND VGND VPWR VPWR sky130_fd_sc_hd__decap_3
XFILLER_52_531 VGND VGND VPWR VPWR sky130_fd_sc_hd__fill_1
XFILLER_64_391 VGND VGND VPWR VPWR sky130_fd_sc_hd__decap_3
XTAP_TAPCELL_ROW_65_1034 VGND VPWR sky130_fd_sc_hd__tapvpwrvgnd_1
XFILLER_24_277 VGND VGND VPWR VPWR sky130_fd_sc_hd__decap_3
XFILLER_52_586 VGND VGND VPWR VPWR sky130_fd_sc_hd__fill_2
X_4949_ _4967_/A _4967_/B VGND VGND VPWR VPWR _4949_/Y sky130_fd_sc_hd__nand2_2
XFILLER_33_69 VGND VGND VPWR VPWR sky130_fd_sc_hd__decap_3
X_6619_ _6619_/A VGND VGND VPWR VPWR _6619_/Y sky130_fd_sc_hd__inv_2
XFILLER_106_533 VGND VGND VPWR VPWR sky130_fd_sc_hd__decap_3
XFILLER_4_638 VGND VGND VPWR VPWR sky130_fd_sc_hd__decap_3
XFILLER_3_137 VGND VGND VPWR VPWR sky130_fd_sc_hd__decap_3
XTAP_TAPCELL_ROW_76_1163 VGND VPWR sky130_fd_sc_hd__tapvpwrvgnd_1
XFILLER_79_439 VGND VGND VPWR VPWR sky130_fd_sc_hd__decap_3
XFILLER_58_44 VGND VGND VPWR VPWR sky130_fd_sc_hd__decap_3
XFILLER_59_130 VGND VGND VPWR VPWR sky130_fd_sc_hd__decap_3
XFILLER_58_66 VGND VGND VPWR VPWR sky130_fd_sc_hd__decap_3
XFILLER_58_88 VGND VGND VPWR VPWR sky130_fd_sc_hd__fill_1
XFILLER_59_152 VGND VGND VPWR VPWR sky130_fd_sc_hd__fill_2
XFILLER_59_163 VGND VGND VPWR VPWR sky130_fd_sc_hd__decap_3
XFILLER_87_461 VGND VGND VPWR VPWR sky130_fd_sc_hd__decap_3
XFILLER_101_293 VGND VGND VPWR VPWR sky130_fd_sc_hd__decap_3
XFILLER_114_50 VGND VGND VPWR VPWR sky130_fd_sc_hd__decap_3
XFILLER_47_314 VGND VGND VPWR VPWR sky130_fd_sc_hd__decap_3
XFILLER_59_196 VGND VGND VPWR VPWR sky130_fd_sc_hd__fill_2
XFILLER_75_645 VGND VGND VPWR VPWR sky130_fd_sc_hd__decap_3
XFILLER_114_83 VGND VGND VPWR VPWR sky130_fd_sc_hd__fill_1
XFILLER_114_94 VGND VGND VPWR VPWR sky130_fd_sc_hd__decap_3
XFILLER_74_144 VGND VGND VPWR VPWR sky130_fd_sc_hd__fill_1
XFILLER_74_166 VGND VGND VPWR VPWR sky130_fd_sc_hd__fill_2
XFILLER_74_32 VGND VGND VPWR VPWR sky130_fd_sc_hd__decap_3
XFILLER_62_328 VGND VGND VPWR VPWR sky130_fd_sc_hd__decap_3
XFILLER_62_339 VGND VGND VPWR VPWR sky130_fd_sc_hd__decap_3
XFILLER_74_54 VGND VGND VPWR VPWR sky130_fd_sc_hd__decap_3
XFILLER_90_637 VGND VGND VPWR VPWR sky130_fd_sc_hd__decap_3
XFILLER_90_648 VGND VGND VPWR VPWR sky130_fd_sc_hd__decap_3
XFILLER_15_222 VGND VGND VPWR VPWR sky130_fd_sc_hd__fill_2
XTAP_TAPCELL_ROW_87_1292 VGND VPWR sky130_fd_sc_hd__tapvpwrvgnd_1
XFILLER_15_266 VGND VGND VPWR VPWR sky130_fd_sc_hd__decap_3
XFILLER_90_20 VGND VGND VPWR VPWR sky130_fd_sc_hd__decap_3
XFILLER_15_299 VGND VGND VPWR VPWR sky130_fd_sc_hd__decap_3
XFILLER_30_236 VGND VGND VPWR VPWR sky130_fd_sc_hd__decap_3
XFILLER_70_383 VGND VGND VPWR VPWR sky130_fd_sc_hd__decap_3
XFILLER_90_64 VGND VGND VPWR VPWR sky130_fd_sc_hd__decap_3
XTAP_TAPCELL_ROW_13_412 VGND VPWR sky130_fd_sc_hd__tapvpwrvgnd_1
XFILLER_88_9 VGND VGND VPWR VPWR sky130_fd_sc_hd__decap_3
XFILLER_90_97 VGND VGND VPWR VPWR sky130_fd_sc_hd__decap_3
XTAP_TAPCELL_ROW_41_743 VGND VPWR sky130_fd_sc_hd__tapvpwrvgnd_1
XFILLER_7_443 VGND VGND VPWR VPWR sky130_fd_sc_hd__decap_3
XFILLER_109_393 VGND VGND VPWR VPWR sky130_fd_sc_hd__decap_3
XFILLER_99_84 VGND VGND VPWR VPWR sky130_fd_sc_hd__decap_3
XFILLER_3_682 VGND VGND VPWR VPWR sky130_fd_sc_hd__fill_2
XFILLER_97_214 VGND VGND VPWR VPWR sky130_fd_sc_hd__fill_1
XFILLER_97_225 VGND VGND VPWR VPWR sky130_fd_sc_hd__decap_3
XFILLER_112_536 VGND VGND VPWR VPWR sky130_fd_sc_hd__decap_3
XFILLER_112_569 VGND VGND VPWR VPWR sky130_fd_sc_hd__decap_3
XFILLER_66_601 VGND VGND VPWR VPWR sky130_fd_sc_hd__decap_3
XFILLER_97_269 VGND VGND VPWR VPWR sky130_fd_sc_hd__decap_3
XFILLER_17_3 VGND VGND VPWR VPWR sky130_fd_sc_hd__decap_3
XFILLER_65_111 VGND VGND VPWR VPWR sky130_fd_sc_hd__fill_1
XFILLER_65_122 VGND VGND VPWR VPWR sky130_fd_sc_hd__decap_3
XFILLER_66_634 VGND VGND VPWR VPWR sky130_fd_sc_hd__decap_3
XFILLER_66_645 VGND VGND VPWR VPWR sky130_fd_sc_hd__decap_3
XFILLER_78_483 VGND VGND VPWR VPWR sky130_fd_sc_hd__decap_3
XTAP_TAPCELL_ROW_49_843 VGND VPWR sky130_fd_sc_hd__tapvpwrvgnd_1
XFILLER_66_678 VGND VGND VPWR VPWR sky130_fd_sc_hd__decap_3
XFILLER_81_604 VGND VGND VPWR VPWR sky130_fd_sc_hd__decap_3
X_6970_ _6970_/CLK _6970_/D VGND VGND VPWR VPWR _6970_/Q sky130_fd_sc_hd__dfxtp_2
XFILLER_65_199 VGND VGND VPWR VPWR sky130_fd_sc_hd__fill_2
XFILLER_80_114 VGND VGND VPWR VPWR sky130_fd_sc_hd__decap_3
XFILLER_81_626 VGND VGND VPWR VPWR sky130_fd_sc_hd__decap_3
XFILLER_0_95 VGND VGND VPWR VPWR sky130_fd_sc_hd__decap_3
XFILLER_46_391 VGND VGND VPWR VPWR sky130_fd_sc_hd__decap_3
XFILLER_80_147 VGND VGND VPWR VPWR sky130_fd_sc_hd__decap_3
XFILLER_81_659 VGND VGND VPWR VPWR sky130_fd_sc_hd__decap_3
XFILLER_34_586 VGND VGND VPWR VPWR sky130_fd_sc_hd__fill_2
XFILLER_61_361 VGND VGND VPWR VPWR sky130_fd_sc_hd__decap_3
XFILLER_80_169 VGND VGND VPWR VPWR sky130_fd_sc_hd__decap_3
XFILLER_21_225 VGND VGND VPWR VPWR sky130_fd_sc_hd__decap_3
XFILLER_34_597 VGND VGND VPWR VPWR sky130_fd_sc_hd__fill_2
X_4803_ _7003_/Q _4802_/X _4677_/B _3403_/A VGND VGND VPWR VPWR _4804_/B sky130_fd_sc_hd__o211ai_2
XFILLER_21_269 VGND VGND VPWR VPWR sky130_fd_sc_hd__decap_3
X_4734_ _4726_/X _4729_/Y _7007_/D _4836_/S VGND VGND VPWR VPWR _4734_/X sky130_fd_sc_hd__o22a_2
XFILLER_9_60 VGND VGND VPWR VPWR sky130_fd_sc_hd__decap_3
XFILLER_9_93 VGND VGND VPWR VPWR sky130_fd_sc_hd__decap_3
X_4665_ _7005_/Q _5633_/B VGND VGND VPWR VPWR _4665_/X sky130_fd_sc_hd__or2_2
X_7384_ _7384_/CLK _7384_/D _6664_/Y VGND VGND VPWR VPWR _7384_/Q sky130_fd_sc_hd__dfrtp_2
Xhold900 _7077_/Q VGND VGND VPWR VPWR _7077_/D sky130_fd_sc_hd__dlygate4sd3_1
Xhold911 _6698_/Q VGND VGND VPWR VPWR hold911/X sky130_fd_sc_hd__dlygate4sd3_1
Xhold922 _6704_/Q VGND VGND VPWR VPWR hold922/X sky130_fd_sc_hd__dlygate4sd3_1
X_6404_ _6567_/A VGND VGND VPWR VPWR _6404_/Y sky130_fd_sc_hd__inv_2
X_3616_ _4614_/C _3616_/B VGND VGND VPWR VPWR _3616_/Y sky130_fd_sc_hd__nand2_2
XFILLER_115_352 VGND VGND VPWR VPWR sky130_fd_sc_hd__decap_3
Xhold933 _5682_/X VGND VGND VPWR VPWR _6691_/D sky130_fd_sc_hd__dlygate4sd3_1
Xhold955 _5735_/X VGND VGND VPWR VPWR _6717_/D sky130_fd_sc_hd__dlygate4sd3_1
Xhold944 _6699_/Q VGND VGND VPWR VPWR hold944/X sky130_fd_sc_hd__dlygate4sd3_1
X_6335_ _6568_/A VGND VGND VPWR VPWR _6335_/Y sky130_fd_sc_hd__inv_2
X_3547_ _3547_/A _3547_/B VGND VGND VPWR VPWR _3547_/Y sky130_fd_sc_hd__nand2_2
XFILLER_0_107 VGND VGND VPWR VPWR sky130_fd_sc_hd__decap_3
XFILLER_88_214 VGND VGND VPWR VPWR sky130_fd_sc_hd__fill_1
Xhold988 _7051_/Q VGND VGND VPWR VPWR hold988/X sky130_fd_sc_hd__dlygate4sd3_1
Xhold977 _7406_/Q VGND VGND VPWR VPWR hold977/X sky130_fd_sc_hd__dlygate4sd3_1
Xhold966 _7380_/Q VGND VGND VPWR VPWR hold966/X sky130_fd_sc_hd__dlygate4sd3_1
XFILLER_0_129 VGND VGND VPWR VPWR sky130_fd_sc_hd__decap_3
XFILLER_115_396 VGND VGND VPWR VPWR sky130_fd_sc_hd__decap_3
Xhold999 _7047_/Q VGND VGND VPWR VPWR hold999/X sky130_fd_sc_hd__dlygate4sd3_1
X_6266_ _6522_/A VGND VGND VPWR VPWR _6266_/Y sky130_fd_sc_hd__inv_2
X_3478_ _7216_/Q _4331_/A2 _4517_/S _7029_/Q _3477_/X VGND VGND VPWR VPWR _3478_/X
+ sky130_fd_sc_hd__a221o_2
XFILLER_57_612 VGND VGND VPWR VPWR sky130_fd_sc_hd__decap_3
XFILLER_69_461 VGND VGND VPWR VPWR sky130_fd_sc_hd__decap_3
X_5217_ _5217_/A _5221_/B VGND VGND VPWR VPWR _7220_/D sky130_fd_sc_hd__and2_2
XFILLER_111_591 VGND VGND VPWR VPWR sky130_fd_sc_hd__decap_3
XFILLER_57_623 VGND VGND VPWR VPWR sky130_fd_sc_hd__decap_3
XFILLER_96_291 VGND VGND VPWR VPWR sky130_fd_sc_hd__decap_3
X_5148_ _5144_/A _5071_/A _3618_/C _3540_/X VGND VGND VPWR VPWR _5148_/X sky130_fd_sc_hd__a211o_2
XFILLER_56_155 VGND VGND VPWR VPWR sky130_fd_sc_hd__fill_2
XFILLER_57_656 VGND VGND VPWR VPWR sky130_fd_sc_hd__decap_3
X_5079_ _5156_/S _6987_/D _5078_/X VGND VGND VPWR VPWR _5079_/X sky130_fd_sc_hd__o21a_2
XFILLER_44_317 VGND VGND VPWR VPWR sky130_fd_sc_hd__decap_3
XFILLER_56_177 VGND VGND VPWR VPWR sky130_fd_sc_hd__decap_3
XFILLER_72_648 VGND VGND VPWR VPWR sky130_fd_sc_hd__decap_3
XFILLER_84_486 VGND VGND VPWR VPWR sky130_fd_sc_hd__decap_3
XFILLER_84_497 VGND VGND VPWR VPWR sky130_fd_sc_hd__fill_2
XFILLER_44_24 VGND VGND VPWR VPWR sky130_fd_sc_hd__decap_3
XFILLER_44_35 VGND VGND VPWR VPWR sky130_fd_sc_hd__fill_1
XFILLER_71_147 VGND VGND VPWR VPWR sky130_fd_sc_hd__decap_3
XFILLER_12_203 VGND VGND VPWR VPWR sky130_fd_sc_hd__decap_3
XFILLER_25_553 VGND VGND VPWR VPWR sky130_fd_sc_hd__decap_3
XFILLER_44_46 VGND VGND VPWR VPWR sky130_fd_sc_hd__decap_3
XFILLER_71_169 VGND VGND VPWR VPWR sky130_fd_sc_hd__decap_3
XFILLER_52_383 VGND VGND VPWR VPWR sky130_fd_sc_hd__fill_1
XFILLER_80_681 VGND VGND VPWR VPWR sky130_fd_sc_hd__decap_3
XFILLER_100_52 VGND VGND VPWR VPWR sky130_fd_sc_hd__decap_3
XFILLER_60_12 VGND VGND VPWR VPWR sky130_fd_sc_hd__decap_3
XFILLER_60_45 VGND VGND VPWR VPWR sky130_fd_sc_hd__decap_3
XFILLER_4_424 VGND VGND VPWR VPWR sky130_fd_sc_hd__decap_3
XFILLER_5_18 VGND VGND VPWR VPWR sky130_fd_sc_hd__decap_3
XFILLER_109_72 VGND VGND VPWR VPWR sky130_fd_sc_hd__decap_3
XFILLER_4_457 VGND VGND VPWR VPWR sky130_fd_sc_hd__fill_2
XFILLER_69_21 VGND VGND VPWR VPWR sky130_fd_sc_hd__decap_3
XFILLER_106_374 VGND VGND VPWR VPWR sky130_fd_sc_hd__decap_3
XFILLER_69_87 VGND VGND VPWR VPWR sky130_fd_sc_hd__decap_3
XFILLER_79_225 VGND VGND VPWR VPWR sky130_fd_sc_hd__decap_3
XFILLER_0_641 VGND VGND VPWR VPWR sky130_fd_sc_hd__decap_3
XFILLER_48_601 VGND VGND VPWR VPWR sky130_fd_sc_hd__decap_3
XFILLER_67_409 VGND VGND VPWR VPWR sky130_fd_sc_hd__decap_3
XFILLER_94_206 VGND VGND VPWR VPWR sky130_fd_sc_hd__decap_3
XFILLER_94_217 VGND VGND VPWR VPWR sky130_fd_sc_hd__decap_3
XFILLER_47_122 VGND VGND VPWR VPWR sky130_fd_sc_hd__decap_3
XFILLER_48_634 VGND VGND VPWR VPWR sky130_fd_sc_hd__decap_3
XFILLER_48_645 VGND VGND VPWR VPWR sky130_fd_sc_hd__decap_3
XFILLER_75_420 VGND VGND VPWR VPWR sky130_fd_sc_hd__decap_3
XFILLER_85_20 VGND VGND VPWR VPWR sky130_fd_sc_hd__decap_3
XTAP_TAPCELL_ROW_89_1321 VGND VPWR sky130_fd_sc_hd__tapvpwrvgnd_1
XFILLER_48_678 VGND VGND VPWR VPWR sky130_fd_sc_hd__decap_3
XFILLER_63_604 VGND VGND VPWR VPWR sky130_fd_sc_hd__decap_3
XFILLER_47_166 VGND VGND VPWR VPWR sky130_fd_sc_hd__fill_2
XFILLER_63_626 VGND VGND VPWR VPWR sky130_fd_sc_hd__decap_3
XFILLER_75_475 VGND VGND VPWR VPWR sky130_fd_sc_hd__decap_3
XFILLER_90_401 VGND VGND VPWR VPWR sky130_fd_sc_hd__decap_3
XTAP_TAPCELL_ROW_46_802 VGND VPWR sky130_fd_sc_hd__tapvpwrvgnd_1
XFILLER_47_199 VGND VGND VPWR VPWR sky130_fd_sc_hd__decap_3
XFILLER_62_125 VGND VGND VPWR VPWR sky130_fd_sc_hd__decap_3
XFILLER_62_147 VGND VGND VPWR VPWR sky130_fd_sc_hd__decap_3
XFILLER_63_659 VGND VGND VPWR VPWR sky130_fd_sc_hd__decap_3
XFILLER_31_501 VGND VGND VPWR VPWR sky130_fd_sc_hd__decap_3
XFILLER_62_169 VGND VGND VPWR VPWR sky130_fd_sc_hd__decap_3
XFILLER_70_180 VGND VGND VPWR VPWR sky130_fd_sc_hd__fill_2
XFILLER_86_6 VGND VGND VPWR VPWR sky130_fd_sc_hd__decap_3
XFILLER_116_116 VGND VGND VPWR VPWR sky130_fd_sc_hd__fill_2
XFILLER_7_262 VGND VGND VPWR VPWR sky130_fd_sc_hd__decap_3
X_4450_ _4451_/A _4451_/B VGND VGND VPWR VPWR _4452_/A sky130_fd_sc_hd__and2_2
XFILLER_109_190 VGND VGND VPWR VPWR sky130_fd_sc_hd__decap_3
XFILLER_116_138 VGND VGND VPWR VPWR sky130_fd_sc_hd__fill_2
X_4381_ _4381_/A _4381_/B VGND VGND VPWR VPWR _4967_/B sky130_fd_sc_hd__nand2_2
X_3401_ _4467_/A _3519_/B _5294_/A _3330_/Y VGND VGND VPWR VPWR _3401_/X sky130_fd_sc_hd__a31o_4
X_3332_ _4467_/A _3332_/B VGND VGND VPWR VPWR _3341_/A sky130_fd_sc_hd__nand2_2
XFILLER_98_501 VGND VGND VPWR VPWR sky130_fd_sc_hd__fill_2
XFILLER_112_333 VGND VGND VPWR VPWR sky130_fd_sc_hd__decap_3
XFILLER_98_545 VGND VGND VPWR VPWR sky130_fd_sc_hd__fill_1
XFILLER_58_409 VGND VGND VPWR VPWR sky130_fd_sc_hd__fill_2
XFILLER_98_589 VGND VGND VPWR VPWR sky130_fd_sc_hd__fill_1
XFILLER_38_111 VGND VGND VPWR VPWR sky130_fd_sc_hd__fill_1
XFILLER_39_623 VGND VGND VPWR VPWR sky130_fd_sc_hd__fill_1
XFILLER_85_228 VGND VGND VPWR VPWR sky130_fd_sc_hd__decap_3
X_5002_ _5003_/A _5003_/B _3548_/X VGND VGND VPWR VPWR _5002_/Y sky130_fd_sc_hd__a21oi_2
XFILLER_38_144 VGND VGND VPWR VPWR sky130_fd_sc_hd__decap_3
XFILLER_54_604 VGND VGND VPWR VPWR sky130_fd_sc_hd__decap_3
XFILLER_66_431 VGND VGND VPWR VPWR sky130_fd_sc_hd__fill_2
XFILLER_66_464 VGND VGND VPWR VPWR sky130_fd_sc_hd__decap_3
XFILLER_26_328 VGND VGND VPWR VPWR sky130_fd_sc_hd__decap_3
XFILLER_38_188 VGND VGND VPWR VPWR sky130_fd_sc_hd__decap_3
XFILLER_54_637 VGND VGND VPWR VPWR sky130_fd_sc_hd__decap_3
XFILLER_81_401 VGND VGND VPWR VPWR sky130_fd_sc_hd__decap_3
XFILLER_19_380 VGND VGND VPWR VPWR sky130_fd_sc_hd__decap_3
XFILLER_54_648 VGND VGND VPWR VPWR sky130_fd_sc_hd__decap_3
X_6953_ _6965_/CLK _6953_/D VGND VGND VPWR VPWR _6953_/Q sky130_fd_sc_hd__dfxtp_2
XFILLER_53_158 VGND VGND VPWR VPWR sky130_fd_sc_hd__fill_2
XFILLER_53_169 VGND VGND VPWR VPWR sky130_fd_sc_hd__decap_3
Xclkbuf_3_5__f_clk clkbuf_0_clk/X VGND VGND VPWR VPWR clkbuf_leaf_9_clk/A sky130_fd_sc_hd__clkbuf_16
X_6884_ _7390_/CLK _6884_/D VGND VGND VPWR VPWR _6884_/Q sky130_fd_sc_hd__dfxtp_2
XFILLER_14_27 VGND VGND VPWR VPWR sky130_fd_sc_hd__fill_1
XFILLER_34_383 VGND VGND VPWR VPWR sky130_fd_sc_hd__fill_2
XFILLER_62_681 VGND VGND VPWR VPWR sky130_fd_sc_hd__decap_3
XFILLER_14_38 VGND VGND VPWR VPWR sky130_fd_sc_hd__decap_3
X_5697_ _7354_/Q hold911/X _5721_/S VGND VGND VPWR VPWR _6698_/D sky130_fd_sc_hd__mux2_2
XFILLER_107_105 VGND VGND VPWR VPWR sky130_fd_sc_hd__decap_3
XFILLER_107_116 VGND VGND VPWR VPWR sky130_fd_sc_hd__decap_3
XFILLER_108_628 VGND VGND VPWR VPWR sky130_fd_sc_hd__decap_3
X_4648_ _4648_/A VGND VGND VPWR VPWR _4648_/Y sky130_fd_sc_hd__inv_2
XFILLER_107_149 VGND VGND VPWR VPWR sky130_fd_sc_hd__fill_1
XFILLER_30_59 VGND VGND VPWR VPWR sky130_fd_sc_hd__decap_3
Xhold730 _6925_/Q VGND VGND VPWR VPWR _6925_/D sky130_fd_sc_hd__dlygate4sd3_1
XFILLER_1_405 VGND VGND VPWR VPWR sky130_fd_sc_hd__decap_3
X_7367_ _7372_/CLK _7367_/D _6647_/Y VGND VGND VPWR VPWR _7367_/Q sky130_fd_sc_hd__dfrtp_2
Xhold741 _6969_/Q VGND VGND VPWR VPWR _6969_/D sky130_fd_sc_hd__dlygate4sd3_1
Xhold752 _6771_/Q VGND VGND VPWR VPWR _6771_/D sky130_fd_sc_hd__dlygate4sd3_1
Xhold763 _6870_/Q VGND VGND VPWR VPWR _6870_/D sky130_fd_sc_hd__dlygate4sd3_1
X_4579_ _4579_/A _4595_/B VGND VGND VPWR VPWR _7291_/D sky130_fd_sc_hd__and2_2
XTAP_TAPCELL_ROW_73_1122 VGND VPWR sky130_fd_sc_hd__tapvpwrvgnd_1
XFILLER_115_193 VGND VGND VPWR VPWR sky130_fd_sc_hd__decap_3
XFILLER_1_438 VGND VGND VPWR VPWR sky130_fd_sc_hd__decap_3
XFILLER_1_449 VGND VGND VPWR VPWR sky130_fd_sc_hd__decap_3
XFILLER_89_545 VGND VGND VPWR VPWR sky130_fd_sc_hd__decap_3
X_7298_ _7397_/CLK _7298_/D _6578_/Y VGND VGND VPWR VPWR _7298_/Q sky130_fd_sc_hd__dfrtp_2
Xhold774 _6842_/Q VGND VGND VPWR VPWR _6842_/D sky130_fd_sc_hd__dlygate4sd3_1
Xhold785 _6837_/Q VGND VGND VPWR VPWR _6837_/D sky130_fd_sc_hd__dlygate4sd3_1
Xhold796 _6946_/Q VGND VGND VPWR VPWR _6946_/D sky130_fd_sc_hd__dlygate4sd3_1
X_6318_ _6674_/A VGND VGND VPWR VPWR _6318_/Y sky130_fd_sc_hd__inv_2
XTAP_TAPCELL_ROW_73_1133 VGND VPWR sky130_fd_sc_hd__tapvpwrvgnd_1
XFILLER_39_57 VGND VGND VPWR VPWR sky130_fd_sc_hd__fill_2
XFILLER_103_388 VGND VGND VPWR VPWR sky130_fd_sc_hd__decap_3
XFILLER_76_228 VGND VGND VPWR VPWR sky130_fd_sc_hd__decap_3
XFILLER_45_604 VGND VGND VPWR VPWR sky130_fd_sc_hd__decap_3
XFILLER_45_626 VGND VGND VPWR VPWR sky130_fd_sc_hd__decap_3
XFILLER_55_12 VGND VGND VPWR VPWR sky130_fd_sc_hd__decap_3
XFILLER_84_250 VGND VGND VPWR VPWR sky130_fd_sc_hd__fill_2
XFILLER_84_261 VGND VGND VPWR VPWR sky130_fd_sc_hd__decap_3
XTAP_TAPCELL_ROW_4_298 VGND VPWR sky130_fd_sc_hd__tapvpwrvgnd_1
XFILLER_29_199 VGND VGND VPWR VPWR sky130_fd_sc_hd__decap_3
XFILLER_55_78 VGND VGND VPWR VPWR sky130_fd_sc_hd__decap_3
XFILLER_72_456 VGND VGND VPWR VPWR sky130_fd_sc_hd__decap_3
XFILLER_32_309 VGND VGND VPWR VPWR sky130_fd_sc_hd__decap_3
XFILLER_44_169 VGND VGND VPWR VPWR sky130_fd_sc_hd__fill_2
XFILLER_60_607 VGND VGND VPWR VPWR sky130_fd_sc_hd__decap_3
XTAP_TAPCELL_ROW_84_1262 VGND VPWR sky130_fd_sc_hd__tapvpwrvgnd_1
XFILLER_111_84 VGND VGND VPWR VPWR sky130_fd_sc_hd__decap_3
XFILLER_13_567 VGND VGND VPWR VPWR sky130_fd_sc_hd__fill_1
XFILLER_71_33 VGND VGND VPWR VPWR sky130_fd_sc_hd__fill_2
XFILLER_71_44 VGND VGND VPWR VPWR sky130_fd_sc_hd__decap_3
XTAP_TAPCELL_ROW_51_860 VGND VPWR sky130_fd_sc_hd__tapvpwrvgnd_1
XFILLER_107_650 VGND VGND VPWR VPWR sky130_fd_sc_hd__decap_3
XFILLER_113_108 VGND VGND VPWR VPWR sky130_fd_sc_hd__decap_3
XFILLER_113_119 VGND VGND VPWR VPWR sky130_fd_sc_hd__decap_3
XFILLER_20_70 VGND VGND VPWR VPWR sky130_fd_sc_hd__decap_3
XFILLER_4_265 VGND VGND VPWR VPWR sky130_fd_sc_hd__decap_3
XTAP_TAPCELL_ROW_95_1391 VGND VPWR sky130_fd_sc_hd__tapvpwrvgnd_1
XFILLER_4_298 VGND VGND VPWR VPWR sky130_fd_sc_hd__fill_1
XFILLER_96_41 VGND VGND VPWR VPWR sky130_fd_sc_hd__decap_3
XFILLER_67_217 VGND VGND VPWR VPWR sky130_fd_sc_hd__decap_3
XFILLER_67_228 VGND VGND VPWR VPWR sky130_fd_sc_hd__decap_3
XFILLER_95_537 VGND VGND VPWR VPWR sky130_fd_sc_hd__decap_3
XFILLER_96_85 VGND VGND VPWR VPWR sky130_fd_sc_hd__decap_3
XFILLER_48_442 VGND VGND VPWR VPWR sky130_fd_sc_hd__fill_1
XFILLER_36_615 VGND VGND VPWR VPWR sky130_fd_sc_hd__decap_3
XFILLER_48_475 VGND VGND VPWR VPWR sky130_fd_sc_hd__fill_1
XFILLER_63_412 VGND VGND VPWR VPWR sky130_fd_sc_hd__decap_3
XFILLER_82_209 VGND VGND VPWR VPWR sky130_fd_sc_hd__decap_3
XTAP_TAPCELL_ROW_59_960 VGND VPWR sky130_fd_sc_hd__tapvpwrvgnd_1
XFILLER_35_125 VGND VGND VPWR VPWR sky130_fd_sc_hd__decap_3
XFILLER_36_648 VGND VGND VPWR VPWR sky130_fd_sc_hd__fill_2
XFILLER_48_497 VGND VGND VPWR VPWR sky130_fd_sc_hd__fill_2
XFILLER_63_456 VGND VGND VPWR VPWR sky130_fd_sc_hd__decap_3
Xplace401 _4528_/B VGND VGND VPWR VPWR _4522_/S sky130_fd_sc_hd__buf_2
Xplace412 _4354_/B1 VGND VGND VPWR VPWR _4261_/A2 sky130_fd_sc_hd__buf_2
XFILLER_51_629 VGND VGND VPWR VPWR sky130_fd_sc_hd__decap_3
XFILLER_63_467 VGND VGND VPWR VPWR sky130_fd_sc_hd__decap_3
XFILLER_90_253 VGND VGND VPWR VPWR sky130_fd_sc_hd__decap_3
Xplace423 _4268_/A2 VGND VGND VPWR VPWR _3958_/S sky130_fd_sc_hd__buf_2
Xplace434 _3366_/X VGND VGND VPWR VPWR _4339_/B1 sky130_fd_sc_hd__buf_2
Xplace445 _5647_/A VGND VGND VPWR VPWR _4909_/A sky130_fd_sc_hd__buf_2
Xplace456 _3327_/A VGND VGND VPWR VPWR _3371_/A sky130_fd_sc_hd__buf_2
XFILLER_16_361 VGND VGND VPWR VPWR sky130_fd_sc_hd__decap_3
XFILLER_44_670 VGND VGND VPWR VPWR sky130_fd_sc_hd__decap_3
XFILLER_50_117 VGND VGND VPWR VPWR sky130_fd_sc_hd__decap_3
XFILLER_31_331 VGND VGND VPWR VPWR sky130_fd_sc_hd__fill_2
X_3881_ _6724_/Q _3884_/A2 _3883_/B1 _6719_/Q VGND VGND VPWR VPWR _3881_/X sky130_fd_sc_hd__a22o_2
XFILLER_31_364 VGND VGND VPWR VPWR sky130_fd_sc_hd__fill_1
XFILLER_31_386 VGND VGND VPWR VPWR sky130_fd_sc_hd__decap_3
XFILLER_84_3 VGND VGND VPWR VPWR sky130_fd_sc_hd__decap_3
XFILLER_6_50 VGND VGND VPWR VPWR sky130_fd_sc_hd__decap_3
X_7221_ clkload3/A _7221_/D _6501_/Y VGND VGND VPWR VPWR _7221_/Q sky130_fd_sc_hd__dfrtp_2
XFILLER_6_83 VGND VGND VPWR VPWR sky130_fd_sc_hd__fill_1
XFILLER_6_94 VGND VGND VPWR VPWR sky130_fd_sc_hd__decap_3
X_4433_ _7239_/Q _4433_/B VGND VGND VPWR VPWR _4433_/X sky130_fd_sc_hd__and2_2
XFILLER_113_620 VGND VGND VPWR VPWR sky130_fd_sc_hd__decap_3
XFILLER_116_29 VGND VGND VPWR VPWR sky130_fd_sc_hd__decap_3
X_7152_ _7312_/CLK _7152_/D _6432_/Y VGND VGND VPWR VPWR _7152_/Q sky130_fd_sc_hd__dfrtp_2
X_4364_ _4364_/A _4364_/B VGND VGND VPWR VPWR _4364_/Y sky130_fd_sc_hd__nor2_2
XFILLER_98_331 VGND VGND VPWR VPWR sky130_fd_sc_hd__decap_3
XFILLER_112_130 VGND VGND VPWR VPWR sky130_fd_sc_hd__decap_3
XFILLER_112_141 VGND VGND VPWR VPWR sky130_fd_sc_hd__decap_3
XFILLER_113_653 VGND VGND VPWR VPWR sky130_fd_sc_hd__decap_3
XFILLER_58_206 VGND VGND VPWR VPWR sky130_fd_sc_hd__decap_3
XFILLER_86_504 VGND VGND VPWR VPWR sky130_fd_sc_hd__decap_3
X_7083_ _7234_/CLK _7083_/D _6363_/Y VGND VGND VPWR VPWR _7083_/Q sky130_fd_sc_hd__dfrtp_2
X_4295_ _3607_/B _4295_/B VGND VGND VPWR VPWR _4295_/X sky130_fd_sc_hd__and2b_2
XFILLER_100_303 VGND VGND VPWR VPWR sky130_fd_sc_hd__decap_3
XFILLER_100_314 VGND VGND VPWR VPWR sky130_fd_sc_hd__fill_2
XFILLER_112_174 VGND VGND VPWR VPWR sky130_fd_sc_hd__decap_3
XFILLER_98_397 VGND VGND VPWR VPWR sky130_fd_sc_hd__decap_3
XFILLER_100_358 VGND VGND VPWR VPWR sky130_fd_sc_hd__decap_3
XFILLER_54_401 VGND VGND VPWR VPWR sky130_fd_sc_hd__decap_3
XFILLER_66_272 VGND VGND VPWR VPWR sky130_fd_sc_hd__decap_3
XFILLER_66_283 VGND VGND VPWR VPWR sky130_fd_sc_hd__decap_3
XFILLER_81_231 VGND VGND VPWR VPWR sky130_fd_sc_hd__decap_3
XFILLER_94_592 VGND VGND VPWR VPWR sky130_fd_sc_hd__decap_3
XTAP_TAPCELL_ROW_107_1538 VGND VPWR sky130_fd_sc_hd__tapvpwrvgnd_1
XFILLER_14_309 VGND VGND VPWR VPWR sky130_fd_sc_hd__fill_2
XFILLER_25_15 VGND VGND VPWR VPWR sky130_fd_sc_hd__decap_3
XFILLER_26_169 VGND VGND VPWR VPWR sky130_fd_sc_hd__decap_3
XFILLER_42_618 VGND VGND VPWR VPWR sky130_fd_sc_hd__decap_3
X_6936_ _7386_/CLK _6936_/D VGND VGND VPWR VPWR _6936_/Q sky130_fd_sc_hd__dfxtp_2
XTAP_TAPCELL_ROW_1_268 VGND VPWR sky130_fd_sc_hd__tapvpwrvgnd_1
XFILLER_41_128 VGND VGND VPWR VPWR sky130_fd_sc_hd__decap_3
XTAP_TAPCELL_ROW_37_698 VGND VPWR sky130_fd_sc_hd__tapvpwrvgnd_1
XFILLER_34_191 VGND VGND VPWR VPWR sky130_fd_sc_hd__decap_3
XFILLER_50_651 VGND VGND VPWR VPWR sky130_fd_sc_hd__decap_3
X_6867_ _7383_/CLK _6867_/D VGND VGND VPWR VPWR _6867_/Q sky130_fd_sc_hd__dfxtp_2
XFILLER_41_14 VGND VGND VPWR VPWR sky130_fd_sc_hd__decap_3
XFILLER_50_684 VGND VGND VPWR VPWR sky130_fd_sc_hd__decap_3
X_6798_ _7405_/CLK _6798_/D VGND VGND VPWR VPWR _6798_/Q sky130_fd_sc_hd__dfxtp_2
XFILLER_41_47 VGND VGND VPWR VPWR sky130_fd_sc_hd__decap_3
XFILLER_41_69 VGND VGND VPWR VPWR sky130_fd_sc_hd__decap_3
XFILLER_104_631 VGND VGND VPWR VPWR sky130_fd_sc_hd__decap_3
XFILLER_116_480 VGND VGND VPWR VPWR sky130_fd_sc_hd__decap_3
XTAP_TAPCELL_ROW_9_357 VGND VPWR sky130_fd_sc_hd__tapvpwrvgnd_1
XFILLER_104_675 VGND VGND VPWR VPWR sky130_fd_sc_hd__decap_3
Xhold593 _6864_/Q VGND VGND VPWR VPWR _6864_/D sky130_fd_sc_hd__dlygate4sd3_1
XFILLER_106_62 VGND VGND VPWR VPWR sky130_fd_sc_hd__decap_3
XFILLER_49_239 VGND VGND VPWR VPWR sky130_fd_sc_hd__decap_3
XFILLER_89_375 VGND VGND VPWR VPWR sky130_fd_sc_hd__fill_1
XFILLER_77_559 VGND VGND VPWR VPWR sky130_fd_sc_hd__fill_1
XFILLER_92_507 VGND VGND VPWR VPWR sky130_fd_sc_hd__decap_3
XFILLER_57_272 VGND VGND VPWR VPWR sky130_fd_sc_hd__decap_3
XFILLER_66_66 VGND VGND VPWR VPWR sky130_fd_sc_hd__fill_1
XFILLER_18_637 VGND VGND VPWR VPWR sky130_fd_sc_hd__decap_3
XFILLER_18_648 VGND VGND VPWR VPWR sky130_fd_sc_hd__decap_3
XFILLER_82_21 VGND VGND VPWR VPWR sky130_fd_sc_hd__decap_3
XFILLER_45_489 VGND VGND VPWR VPWR sky130_fd_sc_hd__decap_3
XFILLER_82_65 VGND VGND VPWR VPWR sky130_fd_sc_hd__decap_3
XFILLER_13_320 VGND VGND VPWR VPWR sky130_fd_sc_hd__decap_3
XFILLER_25_180 VGND VGND VPWR VPWR sky130_fd_sc_hd__decap_3
XFILLER_13_375 VGND VGND VPWR VPWR sky130_fd_sc_hd__decap_3
XFILLER_40_161 VGND VGND VPWR VPWR sky130_fd_sc_hd__decap_3
XFILLER_41_662 VGND VGND VPWR VPWR sky130_fd_sc_hd__decap_3
XFILLER_41_673 VGND VGND VPWR VPWR sky130_fd_sc_hd__decap_3
XFILLER_9_302 VGND VGND VPWR VPWR sky130_fd_sc_hd__fill_1
XFILLER_9_346 VGND VGND VPWR VPWR sky130_fd_sc_hd__decap_3
XFILLER_70_9 VGND VGND VPWR VPWR sky130_fd_sc_hd__decap_3
XTAP_TAPCELL_ROW_97_1420 VGND VPWR sky130_fd_sc_hd__tapvpwrvgnd_1
XFILLER_31_91 VGND VGND VPWR VPWR sky130_fd_sc_hd__decap_3
XFILLER_49_6 VGND VGND VPWR VPWR sky130_fd_sc_hd__decap_3
XFILLER_110_601 VGND VGND VPWR VPWR sky130_fd_sc_hd__decap_3
XFILLER_110_634 VGND VGND VPWR VPWR sky130_fd_sc_hd__decap_3
XFILLER_110_645 VGND VGND VPWR VPWR sky130_fd_sc_hd__decap_3
X_4080_ _4075_/X _4079_/X _4425_/A VGND VGND VPWR VPWR _4451_/B sky130_fd_sc_hd__o21ai_2
XFILLER_110_678 VGND VGND VPWR VPWR sky130_fd_sc_hd__decap_3
XFILLER_36_445 VGND VGND VPWR VPWR sky130_fd_sc_hd__decap_3
XFILLER_48_294 VGND VGND VPWR VPWR sky130_fd_sc_hd__decap_3
XFILLER_63_220 VGND VGND VPWR VPWR sky130_fd_sc_hd__decap_3
XFILLER_76_581 VGND VGND VPWR VPWR sky130_fd_sc_hd__decap_3
XFILLER_63_231 VGND VGND VPWR VPWR sky130_fd_sc_hd__decap_3
XFILLER_63_242 VGND VGND VPWR VPWR sky130_fd_sc_hd__decap_3
XFILLER_63_264 VGND VGND VPWR VPWR sky130_fd_sc_hd__decap_3
XFILLER_91_551 VGND VGND VPWR VPWR sky130_fd_sc_hd__decap_3
Xplace264 _5660_/A VGND VGND VPWR VPWR _3629_/A sky130_fd_sc_hd__buf_2
X_4982_ _6992_/Q _4982_/B _5009_/A VGND VGND VPWR VPWR _4983_/C sky130_fd_sc_hd__or3_2
XFILLER_23_139 VGND VGND VPWR VPWR sky130_fd_sc_hd__decap_3
Xplace297 _3651_/Y VGND VGND VPWR VPWR _3913_/A2 sky130_fd_sc_hd__buf_2
Xplace286 _3889_/B1 VGND VGND VPWR VPWR _3884_/B1 sky130_fd_sc_hd__buf_2
Xplace275 _3884_/A2 VGND VGND VPWR VPWR _3902_/A2 sky130_fd_sc_hd__buf_2
X_6721_ _6971_/CLK _6721_/D VGND VGND VPWR VPWR _6721_/Q sky130_fd_sc_hd__dfxtp_2
X_3933_ _7373_/Q _4476_/A0 _3935_/S VGND VGND VPWR VPWR _7373_/D sky130_fd_sc_hd__mux2_2
XTAP_TAPCELL_ROW_34_657 VGND VPWR sky130_fd_sc_hd__tapvpwrvgnd_1
X_6652_ _6652_/A VGND VGND VPWR VPWR _6652_/Y sky130_fd_sc_hd__inv_2
X_3864_ _3864_/A0 _3863_/X _3864_/S VGND VGND VPWR VPWR _7385_/D sky130_fd_sc_hd__mux2_2
XTAP_TAPCELL_ROW_62_999 VGND VPWR sky130_fd_sc_hd__tapvpwrvgnd_1
XTAP_TAPCELL_ROW_102_1479 VGND VPWR sky130_fd_sc_hd__tapvpwrvgnd_1
XFILLER_31_172 VGND VGND VPWR VPWR sky130_fd_sc_hd__decap_3
X_6583_ _6587_/A VGND VGND VPWR VPWR _6583_/Y sky130_fd_sc_hd__inv_2
X_3795_ _6971_/Q _3884_/B1 _3888_/B1 _6721_/Q VGND VGND VPWR VPWR _3795_/X sky130_fd_sc_hd__a22o_2
XFILLER_11_39 VGND VGND VPWR VPWR sky130_fd_sc_hd__decap_3
XFILLER_105_417 VGND VGND VPWR VPWR sky130_fd_sc_hd__fill_1
X_7204_ _7397_/CLK _7204_/D _6484_/Y VGND VGND VPWR VPWR _7204_/Q sky130_fd_sc_hd__dfrtp_2
X_4416_ _7368_/Q _4435_/B1 _4436_/B1 _7176_/Q _4415_/X VGND VGND VPWR VPWR _4416_/X
+ sky130_fd_sc_hd__a221o_2
X_7135_ _7364_/CLK _7135_/D _6415_/Y VGND VGND VPWR VPWR _7135_/Q sky130_fd_sc_hd__dfrtp_2
X_5396_ _5396_/A0 _4978_/X _5396_/S VGND VGND VPWR VPWR _7135_/D sky130_fd_sc_hd__mux2_2
XFILLER_99_673 VGND VGND VPWR VPWR sky130_fd_sc_hd__decap_3
XFILLER_99_662 VGND VGND VPWR VPWR sky130_fd_sc_hd__decap_3
XFILLER_101_623 VGND VGND VPWR VPWR sky130_fd_sc_hd__decap_3
X_4347_ _7289_/Q _4517_/S _4346_/X _4347_/C1 VGND VGND VPWR VPWR _4347_/X sky130_fd_sc_hd__a211o_2
XTAP_TAPCELL_ROW_6_327 VGND VPWR sky130_fd_sc_hd__tapvpwrvgnd_1
XFILLER_98_161 VGND VGND VPWR VPWR sky130_fd_sc_hd__decap_3
XFILLER_100_122 VGND VGND VPWR VPWR sky130_fd_sc_hd__decap_3
XFILLER_101_656 VGND VGND VPWR VPWR sky130_fd_sc_hd__decap_3
X_7066_ clkload7/A _7066_/D _6346_/Y VGND VGND VPWR VPWR _7066_/Q sky130_fd_sc_hd__dfrtp_2
X_4278_ _7286_/Q _4522_/S _4338_/B1 _7350_/Q _3556_/A VGND VGND VPWR VPWR _4278_/X
+ sky130_fd_sc_hd__a221o_2
XFILLER_98_194 VGND VGND VPWR VPWR sky130_fd_sc_hd__fill_2
XFILLER_100_177 VGND VGND VPWR VPWR sky130_fd_sc_hd__fill_1
XFILLER_46_209 VGND VGND VPWR VPWR sky130_fd_sc_hd__decap_3
XFILLER_86_389 VGND VGND VPWR VPWR sky130_fd_sc_hd__decap_3
XFILLER_15_607 VGND VGND VPWR VPWR sky130_fd_sc_hd__decap_3
XFILLER_27_478 VGND VGND VPWR VPWR sky130_fd_sc_hd__decap_3
XFILLER_54_242 VGND VGND VPWR VPWR sky130_fd_sc_hd__fill_1
XFILLER_54_253 VGND VGND VPWR VPWR sky130_fd_sc_hd__decap_3
XFILLER_82_551 VGND VGND VPWR VPWR sky130_fd_sc_hd__decap_3
XTAP_TAPCELL_ROW_68_1065 VGND VPWR sky130_fd_sc_hd__tapvpwrvgnd_1
XFILLER_82_595 VGND VGND VPWR VPWR sky130_fd_sc_hd__decap_3
XFILLER_42_448 VGND VGND VPWR VPWR sky130_fd_sc_hd__decap_3
X_6919_ _7383_/CLK _6919_/D VGND VGND VPWR VPWR _6919_/Q sky130_fd_sc_hd__dfxtp_2
XTAP_TAPCELL_ROW_81_1221 VGND VPWR sky130_fd_sc_hd__tapvpwrvgnd_1
XFILLER_23_673 VGND VGND VPWR VPWR sky130_fd_sc_hd__fill_2
XFILLER_10_312 VGND VGND VPWR VPWR sky130_fd_sc_hd__decap_3
XFILLER_22_172 VGND VGND VPWR VPWR sky130_fd_sc_hd__decap_3
XFILLER_22_183 VGND VGND VPWR VPWR sky130_fd_sc_hd__fill_1
XFILLER_52_68 VGND VGND VPWR VPWR sky130_fd_sc_hd__decap_3
XFILLER_108_200 VGND VGND VPWR VPWR sky130_fd_sc_hd__decap_3
XTAP_TAPCELL_ROW_79_1194 VGND VPWR sky130_fd_sc_hd__tapvpwrvgnd_1
XFILLER_96_109 VGND VGND VPWR VPWR sky130_fd_sc_hd__decap_3
XTAP_TAPCELL_ROW_92_1361 VGND VPWR sky130_fd_sc_hd__tapvpwrvgnd_1
XTAP_TAPCELL_ROW_92_1350 VGND VPWR sky130_fd_sc_hd__tapvpwrvgnd_1
XFILLER_104_483 VGND VGND VPWR VPWR sky130_fd_sc_hd__fill_1
XFILLER_77_301 VGND VGND VPWR VPWR sky130_fd_sc_hd__decap_3
XFILLER_77_32 VGND VGND VPWR VPWR sky130_fd_sc_hd__decap_3
XFILLER_77_76 VGND VGND VPWR VPWR sky130_fd_sc_hd__decap_3
XFILLER_77_389 VGND VGND VPWR VPWR sky130_fd_sc_hd__decap_3
XFILLER_77_98 VGND VGND VPWR VPWR sky130_fd_sc_hd__decap_3
XFILLER_18_412 VGND VGND VPWR VPWR sky130_fd_sc_hd__decap_3
XFILLER_45_220 VGND VGND VPWR VPWR sky130_fd_sc_hd__decap_3
XFILLER_58_581 VGND VGND VPWR VPWR sky130_fd_sc_hd__decap_3
XFILLER_58_592 VGND VGND VPWR VPWR sky130_fd_sc_hd__decap_3
XFILLER_45_231 VGND VGND VPWR VPWR sky130_fd_sc_hd__fill_1
XFILLER_73_551 VGND VGND VPWR VPWR sky130_fd_sc_hd__decap_3
XFILLER_93_53 VGND VGND VPWR VPWR sky130_fd_sc_hd__decap_3
Xhold1090 _7325_/Q VGND VGND VPWR VPWR _4509_/A1 sky130_fd_sc_hd__dlygate4sd3_1
XFILLER_45_264 VGND VGND VPWR VPWR sky130_fd_sc_hd__fill_2
XFILLER_45_275 VGND VGND VPWR VPWR sky130_fd_sc_hd__decap_3
XFILLER_73_584 VGND VGND VPWR VPWR sky130_fd_sc_hd__decap_3
XFILLER_26_91 VGND VGND VPWR VPWR sky130_fd_sc_hd__decap_3
XFILLER_60_256 VGND VGND VPWR VPWR sky130_fd_sc_hd__decap_3
XFILLER_14_651 VGND VGND VPWR VPWR sky130_fd_sc_hd__decap_3
XTAP_TAPCELL_ROW_31_627 VGND VPWR sky130_fd_sc_hd__tapvpwrvgnd_1
X_3580_ _7033_/Q _4534_/S _4332_/B1 _7380_/Q VGND VGND VPWR VPWR _3580_/X sky130_fd_sc_hd__a22o_2
XTAP_TAPCELL_ROW_11_384 VGND VPWR sky130_fd_sc_hd__tapvpwrvgnd_1
XFILLER_114_203 VGND VGND VPWR VPWR sky130_fd_sc_hd__decap_3
XFILLER_114_236 VGND VGND VPWR VPWR sky130_fd_sc_hd__decap_3
XFILLER_47_3 VGND VGND VPWR VPWR sky130_fd_sc_hd__decap_3
XFILLER_5_393 VGND VGND VPWR VPWR sky130_fd_sc_hd__decap_3
X_4201_ _4186_/A _4636_/B _4200_/X VGND VGND VPWR VPWR _4201_/X sky130_fd_sc_hd__o21a_2
XFILLER_68_301 VGND VGND VPWR VPWR sky130_fd_sc_hd__decap_3
XFILLER_68_312 VGND VGND VPWR VPWR sky130_fd_sc_hd__decap_3
XFILLER_3_51 VGND VGND VPWR VPWR sky130_fd_sc_hd__decap_3
XFILLER_96_632 VGND VGND VPWR VPWR sky130_fd_sc_hd__decap_3
XFILLER_96_654 VGND VGND VPWR VPWR sky130_fd_sc_hd__decap_3
X_4132_ _7075_/Q _4432_/A2 _4432_/B1 _4131_/X VGND VGND VPWR VPWR _4207_/A sky130_fd_sc_hd__o211ai_2
XFILLER_28_209 VGND VGND VPWR VPWR sky130_fd_sc_hd__decap_3
XFILLER_3_84 VGND VGND VPWR VPWR sky130_fd_sc_hd__decap_3
XFILLER_68_378 VGND VGND VPWR VPWR sky130_fd_sc_hd__decap_3
XFILLER_95_175 VGND VGND VPWR VPWR sky130_fd_sc_hd__decap_3
XFILLER_96_687 VGND VGND VPWR VPWR sky130_fd_sc_hd__decap_3
X_4063_ _7116_/Q _4434_/A2 _4434_/B1 _7148_/Q VGND VGND VPWR VPWR _4063_/X sky130_fd_sc_hd__a22o_2
XTAP_TAPCELL_ROW_39_716 VGND VPWR sky130_fd_sc_hd__tapvpwrvgnd_1
XFILLER_83_326 VGND VGND VPWR VPWR sky130_fd_sc_hd__fill_1
XFILLER_83_337 VGND VGND VPWR VPWR sky130_fd_sc_hd__fill_2
XFILLER_36_242 VGND VGND VPWR VPWR sky130_fd_sc_hd__decap_3
XFILLER_36_264 VGND VGND VPWR VPWR sky130_fd_sc_hd__decap_3
XFILLER_51_212 VGND VGND VPWR VPWR sky130_fd_sc_hd__decap_3
XFILLER_64_595 VGND VGND VPWR VPWR sky130_fd_sc_hd__decap_3
X_4965_ _4965_/A0 _4964_/X _5028_/S VGND VGND VPWR VPWR _7264_/D sky130_fd_sc_hd__mux2_2
XTAP_TAPCELL_ROW_19_484 VGND VPWR sky130_fd_sc_hd__tapvpwrvgnd_1
XFILLER_51_267 VGND VGND VPWR VPWR sky130_fd_sc_hd__decap_3
X_6704_ clkload9/A _6704_/D VGND VGND VPWR VPWR _6704_/Q sky130_fd_sc_hd__dfxtp_2
XFILLER_20_643 VGND VGND VPWR VPWR sky130_fd_sc_hd__fill_1
X_4896_ _4896_/A _4896_/B VGND VGND VPWR VPWR _4896_/Y sky130_fd_sc_hd__nand2_2
XFILLER_22_27 VGND VGND VPWR VPWR sky130_fd_sc_hd__fill_1
X_6635_ _6635_/A VGND VGND VPWR VPWR _6635_/Y sky130_fd_sc_hd__inv_2
X_3847_ _6946_/Q _3889_/B1 _3883_/B1 _6958_/Q _3846_/X VGND VGND VPWR VPWR _3847_/X
+ sky130_fd_sc_hd__a221o_2
X_6566_ _6567_/A VGND VGND VPWR VPWR _6566_/Y sky130_fd_sc_hd__inv_2
X_3778_ _6930_/Q _3886_/A2 _3917_/B1 _6882_/Q VGND VGND VPWR VPWR _3778_/X sky130_fd_sc_hd__a22o_2
XTAP_TAPCELL_ROW_115_1626 VGND VPWR sky130_fd_sc_hd__tapvpwrvgnd_1
X_6497_ _6562_/A VGND VGND VPWR VPWR _6497_/Y sky130_fd_sc_hd__inv_2
XTAP_TAPCELL_ROW_115_1637 VGND VPWR sky130_fd_sc_hd__tapvpwrvgnd_1
XFILLER_105_258 VGND VGND VPWR VPWR sky130_fd_sc_hd__decap_3
XFILLER_59_312 VGND VGND VPWR VPWR sky130_fd_sc_hd__decap_3
Xoutput495 _3378_/A VGND VGND VPWR VPWR instruction_out[10] sky130_fd_sc_hd__clkdlybuf4s25_1
Xoutput484 _5653_/Y VGND VGND VPWR VPWR alu_result_out[29] sky130_fd_sc_hd__clkdlybuf4s25_1
Xoutput473 place74/X VGND VGND VPWR VPWR alu_result_out[19] sky130_fd_sc_hd__clkdlybuf4s25_1
X_5379_ _5379_/A0 _4836_/X _5386_/S VGND VGND VPWR VPWR _7143_/D sky130_fd_sc_hd__mux2_2
XFILLER_86_131 VGND VGND VPWR VPWR sky130_fd_sc_hd__decap_3
XFILLER_87_632 VGND VGND VPWR VPWR sky130_fd_sc_hd__decap_3
X_7118_ _7372_/CLK _7118_/D _6398_/Y VGND VGND VPWR VPWR _7118_/Q sky130_fd_sc_hd__dfrtp_2
XFILLER_99_492 VGND VGND VPWR VPWR sky130_fd_sc_hd__decap_3
XFILLER_47_24 VGND VGND VPWR VPWR sky130_fd_sc_hd__decap_3
XFILLER_47_46 VGND VGND VPWR VPWR sky130_fd_sc_hd__decap_3
XFILLER_59_378 VGND VGND VPWR VPWR sky130_fd_sc_hd__fill_1
XFILLER_59_389 VGND VGND VPWR VPWR sky130_fd_sc_hd__decap_3
XFILLER_74_304 VGND VGND VPWR VPWR sky130_fd_sc_hd__decap_3
XFILLER_87_665 VGND VGND VPWR VPWR sky130_fd_sc_hd__decap_3
XFILLER_87_676 VGND VGND VPWR VPWR sky130_fd_sc_hd__decap_3
X_7049_ _7398_/CLK _7049_/D _6329_/Y VGND VGND VPWR VPWR _7049_/Q sky130_fd_sc_hd__dfrtp_2
XFILLER_47_57 VGND VGND VPWR VPWR sky130_fd_sc_hd__decap_3
XFILLER_74_348 VGND VGND VPWR VPWR sky130_fd_sc_hd__decap_3
XFILLER_86_175 VGND VGND VPWR VPWR sky130_fd_sc_hd__decap_3
XFILLER_86_186 VGND VGND VPWR VPWR sky130_fd_sc_hd__fill_2
XFILLER_86_197 VGND VGND VPWR VPWR sky130_fd_sc_hd__decap_3
XPHY_EDGE_ROW_29_Right_29 VGND VGND VPWR VPWR sky130_fd_sc_hd__decap_3
XFILLER_103_30 VGND VGND VPWR VPWR sky130_fd_sc_hd__decap_3
XFILLER_27_231 VGND VGND VPWR VPWR sky130_fd_sc_hd__decap_3
XFILLER_103_52 VGND VGND VPWR VPWR sky130_fd_sc_hd__decap_3
XFILLER_42_234 VGND VGND VPWR VPWR sky130_fd_sc_hd__fill_2
XFILLER_63_34 VGND VGND VPWR VPWR sky130_fd_sc_hd__fill_2
XFILLER_63_67 VGND VGND VPWR VPWR sky130_fd_sc_hd__decap_3
XFILLER_30_429 VGND VGND VPWR VPWR sky130_fd_sc_hd__fill_1
XFILLER_42_256 VGND VGND VPWR VPWR sky130_fd_sc_hd__decap_3
XFILLER_23_492 VGND VGND VPWR VPWR sky130_fd_sc_hd__fill_2
XFILLER_70_598 VGND VGND VPWR VPWR sky130_fd_sc_hd__decap_3
XFILLER_8_29 VGND VGND VPWR VPWR sky130_fd_sc_hd__decap_3
XFILLER_11_676 VGND VGND VPWR VPWR sky130_fd_sc_hd__decap_3
XPHY_EDGE_ROW_38_Right_38 VGND VGND VPWR VPWR sky130_fd_sc_hd__decap_3
XFILLER_109_542 VGND VGND VPWR VPWR sky130_fd_sc_hd__decap_3
XFILLER_6_124 VGND VGND VPWR VPWR sky130_fd_sc_hd__decap_3
XFILLER_109_564 VGND VGND VPWR VPWR sky130_fd_sc_hd__decap_3
XFILLER_12_71 VGND VGND VPWR VPWR sky130_fd_sc_hd__decap_3
XFILLER_7_669 VGND VGND VPWR VPWR sky130_fd_sc_hd__decap_3
Xwire578 _6288_/A VGND VGND VPWR VPWR _6285_/A sky130_fd_sc_hd__clkbuf_4
XFILLER_109_597 VGND VGND VPWR VPWR sky130_fd_sc_hd__decap_3
XFILLER_6_179 VGND VGND VPWR VPWR sky130_fd_sc_hd__decap_3
XFILLER_2_330 VGND VGND VPWR VPWR sky130_fd_sc_hd__fill_1
XFILLER_2_341 VGND VGND VPWR VPWR sky130_fd_sc_hd__decap_3
XFILLER_88_42 VGND VGND VPWR VPWR sky130_fd_sc_hd__decap_3
XFILLER_111_217 VGND VGND VPWR VPWR sky130_fd_sc_hd__decap_3
XFILLER_2_374 VGND VGND VPWR VPWR sky130_fd_sc_hd__decap_3
XFILLER_33_9 VGND VGND VPWR VPWR sky130_fd_sc_hd__decap_3
XFILLER_78_643 VGND VGND VPWR VPWR sky130_fd_sc_hd__fill_1
XFILLER_78_654 VGND VGND VPWR VPWR sky130_fd_sc_hd__decap_3
XPHY_EDGE_ROW_47_Right_47 VGND VGND VPWR VPWR sky130_fd_sc_hd__decap_3
XFILLER_65_337 VGND VGND VPWR VPWR sky130_fd_sc_hd__decap_3
XFILLER_92_112 VGND VGND VPWR VPWR sky130_fd_sc_hd__decap_3
XFILLER_93_635 VGND VGND VPWR VPWR sky130_fd_sc_hd__decap_3
XFILLER_18_220 VGND VGND VPWR VPWR sky130_fd_sc_hd__decap_3
XFILLER_18_242 VGND VGND VPWR VPWR sky130_fd_sc_hd__fill_1
XFILLER_80_307 VGND VGND VPWR VPWR sky130_fd_sc_hd__fill_1
XFILLER_93_668 VGND VGND VPWR VPWR sky130_fd_sc_hd__decap_3
XFILLER_93_679 VGND VGND VPWR VPWR sky130_fd_sc_hd__decap_3
XFILLER_18_253 VGND VGND VPWR VPWR sky130_fd_sc_hd__fill_2
XFILLER_37_90 VGND VGND VPWR VPWR sky130_fd_sc_hd__decap_3
XFILLER_46_573 VGND VGND VPWR VPWR sky130_fd_sc_hd__decap_3
XFILLER_46_584 VGND VGND VPWR VPWR sky130_fd_sc_hd__decap_3
XFILLER_46_595 VGND VGND VPWR VPWR sky130_fd_sc_hd__decap_3
XFILLER_73_370 VGND VGND VPWR VPWR sky130_fd_sc_hd__decap_3
XFILLER_80_318 VGND VGND VPWR VPWR sky130_fd_sc_hd__decap_3
XFILLER_33_223 VGND VGND VPWR VPWR sky130_fd_sc_hd__fill_1
XFILLER_33_234 VGND VGND VPWR VPWR sky130_fd_sc_hd__decap_3
XFILLER_61_587 VGND VGND VPWR VPWR sky130_fd_sc_hd__decap_3
XTAP_TAPCELL_ROW_44_774 VGND VPWR sky130_fd_sc_hd__tapvpwrvgnd_1
XTAP_TAPCELL_ROW_16_443 VGND VPWR sky130_fd_sc_hd__tapvpwrvgnd_1
X_4750_ _4909_/A _4750_/B _4750_/C VGND VGND VPWR VPWR _4751_/B sky130_fd_sc_hd__or3_2
XTAP_TAPCELL_ROW_44_785 VGND VPWR sky130_fd_sc_hd__tapvpwrvgnd_1
XPHY_EDGE_ROW_56_Right_56 VGND VGND VPWR VPWR sky130_fd_sc_hd__decap_3
X_4681_ _4982_/B _5009_/A _6992_/Q _6993_/Q _6994_/Q VGND VGND VPWR VPWR _4960_/B
+ sky130_fd_sc_hd__o2111a_2
X_3701_ _3629_/A _3700_/X _4791_/A1 VGND VGND VPWR VPWR _3701_/X sky130_fd_sc_hd__a21o_2
X_6420_ _6548_/A VGND VGND VPWR VPWR _6420_/Y sky130_fd_sc_hd__inv_2
X_3632_ _3630_/A _3501_/X _3502_/X _3505_/B _5020_/A VGND VGND VPWR VPWR _3632_/X
+ sky130_fd_sc_hd__a311o_2
X_6351_ _6388_/A VGND VGND VPWR VPWR _6351_/Y sky130_fd_sc_hd__inv_2
XFILLER_115_523 VGND VGND VPWR VPWR sky130_fd_sc_hd__decap_3
X_5302_ _5302_/A0 _4771_/X _5315_/S VGND VGND VPWR VPWR _7179_/D sky130_fd_sc_hd__mux2_2
XFILLER_115_556 VGND VGND VPWR VPWR sky130_fd_sc_hd__decap_3
XFILLER_115_567 VGND VGND VPWR VPWR sky130_fd_sc_hd__decap_3
XFILLER_6_691 VGND VGND VPWR VPWR sky130_fd_sc_hd__fill_1
XFILLER_88_407 VGND VGND VPWR VPWR sky130_fd_sc_hd__decap_3
X_6282_ _6285_/A VGND VGND VPWR VPWR _6282_/Y sky130_fd_sc_hd__inv_2
X_3494_ _7183_/Q _4471_/S _4354_/B1 _7375_/Q VGND VGND VPWR VPWR _3494_/X sky130_fd_sc_hd__a22o_2
XPHY_EDGE_ROW_65_Right_65 VGND VGND VPWR VPWR sky130_fd_sc_hd__decap_3
XFILLER_102_239 VGND VGND VPWR VPWR sky130_fd_sc_hd__decap_3
XFILLER_69_632 VGND VGND VPWR VPWR sky130_fd_sc_hd__decap_3
XFILLER_110_250 VGND VGND VPWR VPWR sky130_fd_sc_hd__fill_2
XFILLER_68_164 VGND VGND VPWR VPWR sky130_fd_sc_hd__decap_3
XFILLER_69_665 VGND VGND VPWR VPWR sky130_fd_sc_hd__decap_3
XFILLER_69_676 VGND VGND VPWR VPWR sky130_fd_sc_hd__decap_3
XFILLER_84_613 VGND VGND VPWR VPWR sky130_fd_sc_hd__decap_3
XFILLER_96_473 VGND VGND VPWR VPWR sky130_fd_sc_hd__decap_3
X_4115_ _7268_/Q _4356_/A2 _4349_/B1 _7236_/Q _4114_/X VGND VGND VPWR VPWR _4117_/B
+ sky130_fd_sc_hd__a221o_2
XTAP_TAPCELL_ROW_110_1567 VGND VPWR sky130_fd_sc_hd__tapvpwrvgnd_1
XFILLER_110_283 VGND VGND VPWR VPWR sky130_fd_sc_hd__decap_3
XFILLER_56_315 VGND VGND VPWR VPWR sky130_fd_sc_hd__decap_3
XFILLER_56_326 VGND VGND VPWR VPWR sky130_fd_sc_hd__decap_3
XFILLER_68_197 VGND VGND VPWR VPWR sky130_fd_sc_hd__decap_3
XFILLER_83_101 VGND VGND VPWR VPWR sky130_fd_sc_hd__fill_2
X_5095_ _5095_/A0 _5094_/X _5136_/S VGND VGND VPWR VPWR _7256_/D sky130_fd_sc_hd__mux2_2
XFILLER_17_27 VGND VGND VPWR VPWR sky130_fd_sc_hd__decap_3
XFILLER_71_307 VGND VGND VPWR VPWR sky130_fd_sc_hd__decap_3
XFILLER_83_134 VGND VGND VPWR VPWR sky130_fd_sc_hd__decap_3
XFILLER_84_657 VGND VGND VPWR VPWR sky130_fd_sc_hd__decap_3
X_4046_ _7373_/Q _4435_/B1 _4436_/B1 _7181_/Q VGND VGND VPWR VPWR _4046_/X sky130_fd_sc_hd__a22o_2
XFILLER_17_49 VGND VGND VPWR VPWR sky130_fd_sc_hd__decap_3
XFILLER_24_212 VGND VGND VPWR VPWR sky130_fd_sc_hd__decap_3
XFILLER_24_245 VGND VGND VPWR VPWR sky130_fd_sc_hd__decap_3
XFILLER_37_595 VGND VGND VPWR VPWR sky130_fd_sc_hd__decap_3
XFILLER_52_543 VGND VGND VPWR VPWR sky130_fd_sc_hd__fill_2
XFILLER_92_690 VGND VGND VPWR VPWR sky130_fd_sc_hd__fill_2
XTAP_TAPCELL_ROW_65_1035 VGND VPWR sky130_fd_sc_hd__tapvpwrvgnd_1
XFILLER_12_418 VGND VGND VPWR VPWR sky130_fd_sc_hd__fill_2
XFILLER_24_256 VGND VGND VPWR VPWR sky130_fd_sc_hd__decap_3
XFILLER_33_15 VGND VGND VPWR VPWR sky130_fd_sc_hd__fill_1
XPHY_EDGE_ROW_74_Right_74 VGND VGND VPWR VPWR sky130_fd_sc_hd__decap_3
XFILLER_24_289 VGND VGND VPWR VPWR sky130_fd_sc_hd__decap_3
XFILLER_33_37 VGND VGND VPWR VPWR sky130_fd_sc_hd__fill_1
XFILLER_52_598 VGND VGND VPWR VPWR sky130_fd_sc_hd__decap_3
X_4948_ _4948_/A _4948_/B VGND VGND VPWR VPWR _4948_/Y sky130_fd_sc_hd__nor2_2
X_4879_ _4879_/A0 _4878_/X _4901_/S VGND VGND VPWR VPWR _7269_/D sky130_fd_sc_hd__mux2_2
X_6618_ _6682_/A VGND VGND VPWR VPWR _6618_/Y sky130_fd_sc_hd__inv_2
XFILLER_3_105 VGND VGND VPWR VPWR sky130_fd_sc_hd__decap_3
XFILLER_3_116 VGND VGND VPWR VPWR sky130_fd_sc_hd__decap_3
X_6549_ _6584_/A VGND VGND VPWR VPWR _6549_/Y sky130_fd_sc_hd__inv_2
XFILLER_106_545 VGND VGND VPWR VPWR sky130_fd_sc_hd__decap_3
XFILLER_106_567 VGND VGND VPWR VPWR sky130_fd_sc_hd__decap_3
XFILLER_3_149 VGND VGND VPWR VPWR sky130_fd_sc_hd__decap_3
XTAP_TAPCELL_ROW_76_1164 VGND VPWR sky130_fd_sc_hd__tapvpwrvgnd_1
XPHY_EDGE_ROW_83_Right_83 VGND VGND VPWR VPWR sky130_fd_sc_hd__decap_3
XPHY_EDGE_ROW_18_Left_135 VGND VGND VPWR VPWR sky130_fd_sc_hd__decap_3
XFILLER_58_12 VGND VGND VPWR VPWR sky130_fd_sc_hd__decap_3
XFILLER_58_78 VGND VGND VPWR VPWR sky130_fd_sc_hd__decap_3
XFILLER_87_473 VGND VGND VPWR VPWR sky130_fd_sc_hd__decap_3
XFILLER_101_261 VGND VGND VPWR VPWR sky130_fd_sc_hd__decap_3
XFILLER_59_175 VGND VGND VPWR VPWR sky130_fd_sc_hd__decap_3
XFILLER_75_624 VGND VGND VPWR VPWR sky130_fd_sc_hd__decap_3
XFILLER_114_62 VGND VGND VPWR VPWR sky130_fd_sc_hd__decap_3
XFILLER_74_11 VGND VGND VPWR VPWR sky130_fd_sc_hd__decap_3
XFILLER_75_657 VGND VGND VPWR VPWR sky130_fd_sc_hd__decap_3
XFILLER_75_679 VGND VGND VPWR VPWR sky130_fd_sc_hd__decap_3
XFILLER_15_201 VGND VGND VPWR VPWR sky130_fd_sc_hd__decap_3
XPHY_EDGE_ROW_27_Left_144 VGND VGND VPWR VPWR sky130_fd_sc_hd__decap_3
XFILLER_15_234 VGND VGND VPWR VPWR sky130_fd_sc_hd__decap_3
XFILLER_55_381 VGND VGND VPWR VPWR sky130_fd_sc_hd__decap_3
XFILLER_74_99 VGND VGND VPWR VPWR sky130_fd_sc_hd__fill_2
XTAP_TAPCELL_ROW_87_1293 VGND VPWR sky130_fd_sc_hd__tapvpwrvgnd_1
XPHY_EDGE_ROW_92_Right_92 VGND VGND VPWR VPWR sky130_fd_sc_hd__decap_3
XFILLER_15_245 VGND VGND VPWR VPWR sky130_fd_sc_hd__decap_3
XFILLER_70_395 VGND VGND VPWR VPWR sky130_fd_sc_hd__decap_3
XFILLER_90_43 VGND VGND VPWR VPWR sky130_fd_sc_hd__fill_1
XTAP_TAPCELL_ROW_13_413 VGND VPWR sky130_fd_sc_hd__tapvpwrvgnd_1
XTAP_TAPCELL_ROW_13_402 VGND VPWR sky130_fd_sc_hd__tapvpwrvgnd_1
XFILLER_30_248 VGND VGND VPWR VPWR sky130_fd_sc_hd__decap_3
XFILLER_30_259 VGND VGND VPWR VPWR sky130_fd_sc_hd__decap_3
XFILLER_90_76 VGND VGND VPWR VPWR sky130_fd_sc_hd__decap_3
XTAP_TAPCELL_ROW_41_744 VGND VPWR sky130_fd_sc_hd__tapvpwrvgnd_1
XFILLER_23_81 VGND VGND VPWR VPWR sky130_fd_sc_hd__decap_3
XFILLER_7_422 VGND VGND VPWR VPWR sky130_fd_sc_hd__decap_3
XFILLER_116_309 VGND VGND VPWR VPWR sky130_fd_sc_hd__fill_1
XFILLER_7_455 VGND VGND VPWR VPWR sky130_fd_sc_hd__decap_3
XPHY_EDGE_ROW_36_Left_153 VGND VGND VPWR VPWR sky130_fd_sc_hd__decap_3
XFILLER_109_361 VGND VGND VPWR VPWR sky130_fd_sc_hd__decap_3
XFILLER_109_372 VGND VGND VPWR VPWR sky130_fd_sc_hd__decap_3
XFILLER_7_488 VGND VGND VPWR VPWR sky130_fd_sc_hd__fill_2
XFILLER_7_499 VGND VGND VPWR VPWR sky130_fd_sc_hd__decap_3
XFILLER_99_63 VGND VGND VPWR VPWR sky130_fd_sc_hd__decap_3
XFILLER_99_41 VGND VGND VPWR VPWR sky130_fd_sc_hd__decap_3
XFILLER_99_96 VGND VGND VPWR VPWR sky130_fd_sc_hd__decap_3
XFILLER_112_504 VGND VGND VPWR VPWR sky130_fd_sc_hd__fill_1
XFILLER_112_515 VGND VGND VPWR VPWR sky130_fd_sc_hd__decap_3
XFILLER_3_661 VGND VGND VPWR VPWR sky130_fd_sc_hd__decap_3
XFILLER_112_548 VGND VGND VPWR VPWR sky130_fd_sc_hd__decap_3
XFILLER_31_6 VGND VGND VPWR VPWR sky130_fd_sc_hd__decap_3
XFILLER_66_613 VGND VGND VPWR VPWR sky130_fd_sc_hd__decap_3
XFILLER_78_462 VGND VGND VPWR VPWR sky130_fd_sc_hd__decap_3
XFILLER_93_432 VGND VGND VPWR VPWR sky130_fd_sc_hd__decap_3
XFILLER_65_156 VGND VGND VPWR VPWR sky130_fd_sc_hd__decap_3
XFILLER_66_657 VGND VGND VPWR VPWR sky130_fd_sc_hd__decap_3
XTAP_TAPCELL_ROW_49_844 VGND VPWR sky130_fd_sc_hd__tapvpwrvgnd_1
XPHY_EDGE_ROW_45_Left_162 VGND VGND VPWR VPWR sky130_fd_sc_hd__decap_3
XFILLER_0_41 VGND VGND VPWR VPWR sky130_fd_sc_hd__decap_3
XFILLER_19_584 VGND VGND VPWR VPWR sky130_fd_sc_hd__decap_3
XFILLER_53_307 VGND VGND VPWR VPWR sky130_fd_sc_hd__decap_3
XFILLER_65_178 VGND VGND VPWR VPWR sky130_fd_sc_hd__decap_3
XFILLER_81_638 VGND VGND VPWR VPWR sky130_fd_sc_hd__decap_3
XFILLER_0_74 VGND VGND VPWR VPWR sky130_fd_sc_hd__decap_3
XFILLER_0_85 VGND VGND VPWR VPWR sky130_fd_sc_hd__fill_1
XFILLER_74_690 VGND VGND VPWR VPWR sky130_fd_sc_hd__fill_2
XFILLER_80_126 VGND VGND VPWR VPWR sky130_fd_sc_hd__decap_3
XFILLER_61_340 VGND VGND VPWR VPWR sky130_fd_sc_hd__decap_3
XFILLER_21_237 VGND VGND VPWR VPWR sky130_fd_sc_hd__decap_3
XFILLER_61_373 VGND VGND VPWR VPWR sky130_fd_sc_hd__decap_3
XFILLER_61_384 VGND VGND VPWR VPWR sky130_fd_sc_hd__decap_3
X_4802_ _7002_/Q _5633_/B _4834_/A VGND VGND VPWR VPWR _4802_/X sky130_fd_sc_hd__o21a_2
XPHY_EDGE_ROW_100_Right_100 VGND VGND VPWR VPWR sky130_fd_sc_hd__decap_3
XFILLER_9_72 VGND VGND VPWR VPWR sky130_fd_sc_hd__decap_3
XPHY_EDGE_ROW_54_Left_171 VGND VGND VPWR VPWR sky130_fd_sc_hd__decap_3
X_6403_ _6599_/A VGND VGND VPWR VPWR _6403_/Y sky130_fd_sc_hd__inv_2
X_4664_ _5015_/A _4664_/B _5665_/A VGND VGND VPWR VPWR _4664_/X sky130_fd_sc_hd__or3b_4
X_7383_ _7383_/CLK _7383_/D _6663_/Y VGND VGND VPWR VPWR _7383_/Q sky130_fd_sc_hd__dfrtp_2
Xhold901 _7108_/Q VGND VGND VPWR VPWR _7108_/D sky130_fd_sc_hd__dlygate4sd3_1
Xhold912 _6706_/Q VGND VGND VPWR VPWR hold912/X sky130_fd_sc_hd__dlygate4sd3_1
X_4595_ _7283_/Q _4595_/B VGND VGND VPWR VPWR _7283_/D sky130_fd_sc_hd__and2_2
X_3615_ _3508_/A _3547_/Y _3427_/B VGND VGND VPWR VPWR _3616_/B sky130_fd_sc_hd__o21ai_2
XFILLER_115_331 VGND VGND VPWR VPWR sky130_fd_sc_hd__decap_3
Xhold923 _6687_/Q VGND VGND VPWR VPWR hold923/X sky130_fd_sc_hd__dlygate4sd3_1
Xhold934 _7033_/Q VGND VGND VPWR VPWR _5589_/A sky130_fd_sc_hd__dlygate4sd3_1
Xhold945 _7050_/Q VGND VGND VPWR VPWR hold945/X sky130_fd_sc_hd__dlygate4sd3_1
X_6334_ _6684_/A VGND VGND VPWR VPWR _6334_/Y sky130_fd_sc_hd__inv_2
X_3546_ _3630_/A _3630_/B _3635_/A _3636_/A VGND VGND VPWR VPWR _3547_/B sky130_fd_sc_hd__a211o_2
XFILLER_115_364 VGND VGND VPWR VPWR sky130_fd_sc_hd__decap_3
XFILLER_1_609 VGND VGND VPWR VPWR sky130_fd_sc_hd__decap_3
Xhold989 _7389_/Q VGND VGND VPWR VPWR hold989/X sky130_fd_sc_hd__dlygate4sd3_1
Xhold978 _7320_/Q VGND VGND VPWR VPWR hold978/X sky130_fd_sc_hd__dlygate4sd3_1
Xhold967 _7211_/Q VGND VGND VPWR VPWR hold967/X sky130_fd_sc_hd__dlygate4sd3_1
Xhold956 _6711_/Q VGND VGND VPWR VPWR hold956/X sky130_fd_sc_hd__dlygate4sd3_1
X_6265_ _6522_/A VGND VGND VPWR VPWR _6265_/Y sky130_fd_sc_hd__inv_2
XFILLER_103_537 VGND VGND VPWR VPWR sky130_fd_sc_hd__decap_3
X_3477_ _7184_/Q _3996_/S _3380_/Y _7376_/Q VGND VGND VPWR VPWR _3477_/X sky130_fd_sc_hd__a22o_2
XFILLER_111_570 VGND VGND VPWR VPWR sky130_fd_sc_hd__decap_3
XFILLER_28_15 VGND VGND VPWR VPWR sky130_fd_sc_hd__decap_3
XFILLER_28_37 VGND VGND VPWR VPWR sky130_fd_sc_hd__decap_3
XFILLER_29_337 VGND VGND VPWR VPWR sky130_fd_sc_hd__decap_3
XFILLER_57_635 VGND VGND VPWR VPWR sky130_fd_sc_hd__decap_3
XFILLER_84_421 VGND VGND VPWR VPWR sky130_fd_sc_hd__decap_3
XFILLER_96_281 VGND VGND VPWR VPWR sky130_fd_sc_hd__fill_1
X_5147_ _5145_/A _3541_/X _5146_/Y VGND VGND VPWR VPWR _5147_/X sky130_fd_sc_hd__a21o_2
XPHY_EDGE_ROW_63_Left_180 VGND VGND VPWR VPWR sky130_fd_sc_hd__decap_3
XFILLER_56_134 VGND VGND VPWR VPWR sky130_fd_sc_hd__fill_1
XFILLER_57_668 VGND VGND VPWR VPWR sky130_fd_sc_hd__decap_3
XFILLER_57_679 VGND VGND VPWR VPWR sky130_fd_sc_hd__decap_3
XFILLER_84_454 VGND VGND VPWR VPWR sky130_fd_sc_hd__decap_3
X_5078_ _5581_/S _5069_/X _5077_/X _4467_/B _5666_/A VGND VGND VPWR VPWR _5078_/X
+ sky130_fd_sc_hd__a221o_2
XFILLER_44_307 VGND VGND VPWR VPWR sky130_fd_sc_hd__fill_1
XFILLER_44_329 VGND VGND VPWR VPWR sky130_fd_sc_hd__decap_3
XFILLER_71_126 VGND VGND VPWR VPWR sky130_fd_sc_hd__decap_3
XFILLER_44_58 VGND VGND VPWR VPWR sky130_fd_sc_hd__decap_3
XFILLER_52_362 VGND VGND VPWR VPWR sky130_fd_sc_hd__fill_2
XFILLER_71_159 VGND VGND VPWR VPWR sky130_fd_sc_hd__decap_3
XFILLER_80_660 VGND VGND VPWR VPWR sky130_fd_sc_hd__decap_3
XFILLER_12_248 VGND VGND VPWR VPWR sky130_fd_sc_hd__decap_3
XFILLER_100_75 VGND VGND VPWR VPWR sky130_fd_sc_hd__fill_1
XFILLER_60_24 VGND VGND VPWR VPWR sky130_fd_sc_hd__decap_3
XFILLER_20_292 VGND VGND VPWR VPWR sky130_fd_sc_hd__fill_2
XFILLER_60_68 VGND VGND VPWR VPWR sky130_fd_sc_hd__decap_3
XFILLER_114_3 VGND VGND VPWR VPWR sky130_fd_sc_hd__decap_3
XFILLER_4_403 VGND VGND VPWR VPWR sky130_fd_sc_hd__decap_3
XFILLER_109_51 VGND VGND VPWR VPWR sky130_fd_sc_hd__decap_3
XFILLER_4_436 VGND VGND VPWR VPWR sky130_fd_sc_hd__decap_3
XFILLER_109_84 VGND VGND VPWR VPWR sky130_fd_sc_hd__decap_3
XFILLER_69_44 VGND VGND VPWR VPWR sky130_fd_sc_hd__decap_3
XFILLER_69_66 VGND VGND VPWR VPWR sky130_fd_sc_hd__decap_3
XFILLER_0_620 VGND VGND VPWR VPWR sky130_fd_sc_hd__decap_3
XFILLER_106_386 VGND VGND VPWR VPWR sky130_fd_sc_hd__decap_3
XFILLER_69_99 VGND VGND VPWR VPWR sky130_fd_sc_hd__decap_3
XFILLER_79_237 VGND VGND VPWR VPWR sky130_fd_sc_hd__decap_3
XFILLER_102_570 VGND VGND VPWR VPWR sky130_fd_sc_hd__decap_3
XFILLER_47_101 VGND VGND VPWR VPWR sky130_fd_sc_hd__decap_3
XFILLER_48_613 VGND VGND VPWR VPWR sky130_fd_sc_hd__decap_3
XFILLER_85_32 VGND VGND VPWR VPWR sky130_fd_sc_hd__decap_3
XFILLER_87_281 VGND VGND VPWR VPWR sky130_fd_sc_hd__decap_3
XFILLER_94_229 VGND VGND VPWR VPWR sky130_fd_sc_hd__decap_3
XTAP_TAPCELL_ROW_89_1322 VGND VPWR sky130_fd_sc_hd__tapvpwrvgnd_1
XFILLER_48_657 VGND VGND VPWR VPWR sky130_fd_sc_hd__decap_3
XFILLER_85_54 VGND VGND VPWR VPWR sky130_fd_sc_hd__fill_2
XFILLER_85_76 VGND VGND VPWR VPWR sky130_fd_sc_hd__decap_3
XFILLER_18_70 VGND VGND VPWR VPWR sky130_fd_sc_hd__fill_2
XFILLER_35_318 VGND VGND VPWR VPWR sky130_fd_sc_hd__fill_2
XFILLER_62_104 VGND VGND VPWR VPWR sky130_fd_sc_hd__decap_3
XFILLER_63_638 VGND VGND VPWR VPWR sky130_fd_sc_hd__decap_3
XFILLER_90_413 VGND VGND VPWR VPWR sky130_fd_sc_hd__decap_3
XTAP_TAPCELL_ROW_46_803 VGND VPWR sky130_fd_sc_hd__tapvpwrvgnd_1
XFILLER_16_521 VGND VGND VPWR VPWR sky130_fd_sc_hd__decap_3
XFILLER_28_370 VGND VGND VPWR VPWR sky130_fd_sc_hd__decap_3
XFILLER_90_424 VGND VGND VPWR VPWR sky130_fd_sc_hd__decap_3
XFILLER_43_340 VGND VGND VPWR VPWR sky130_fd_sc_hd__fill_1
XFILLER_62_159 VGND VGND VPWR VPWR sky130_fd_sc_hd__fill_2
XFILLER_71_671 VGND VGND VPWR VPWR sky130_fd_sc_hd__fill_1
XFILLER_16_587 VGND VGND VPWR VPWR sky130_fd_sc_hd__fill_1
XFILLER_16_598 VGND VGND VPWR VPWR sky130_fd_sc_hd__fill_1
XFILLER_71_682 VGND VGND VPWR VPWR sky130_fd_sc_hd__decap_3
XTAP_TAPCELL_ROW_26_560 VGND VPWR sky130_fd_sc_hd__tapvpwrvgnd_1
XFILLER_34_91 VGND VGND VPWR VPWR sky130_fd_sc_hd__decap_3
XFILLER_70_192 VGND VGND VPWR VPWR sky130_fd_sc_hd__decap_3
XFILLER_11_270 VGND VGND VPWR VPWR sky130_fd_sc_hd__decap_3
XFILLER_11_281 VGND VGND VPWR VPWR sky130_fd_sc_hd__decap_3
XFILLER_116_106 VGND VGND VPWR VPWR sky130_fd_sc_hd__decap_3
XFILLER_7_274 VGND VGND VPWR VPWR sky130_fd_sc_hd__decap_3
X_4380_ _4380_/A _4380_/B VGND VGND VPWR VPWR _4381_/B sky130_fd_sc_hd__or2_2
X_3400_ _3449_/B VGND VGND VPWR VPWR _3421_/B sky130_fd_sc_hd__inv_2
X_3331_ _3353_/A _3362_/A _3371_/A VGND VGND VPWR VPWR _3528_/A sky130_fd_sc_hd__or3b_2
XFILLER_112_312 VGND VGND VPWR VPWR sky130_fd_sc_hd__fill_1
XFILLER_66_421 VGND VGND VPWR VPWR sky130_fd_sc_hd__decap_3
X_5001_ _5001_/A _5001_/B VGND VGND VPWR VPWR _6991_/D sky130_fd_sc_hd__nor2_2
XFILLER_38_123 VGND VGND VPWR VPWR sky130_fd_sc_hd__decap_3
XFILLER_39_646 VGND VGND VPWR VPWR sky130_fd_sc_hd__fill_2
XFILLER_39_668 VGND VGND VPWR VPWR sky130_fd_sc_hd__decap_3
XFILLER_66_443 VGND VGND VPWR VPWR sky130_fd_sc_hd__decap_3
XFILLER_26_318 VGND VGND VPWR VPWR sky130_fd_sc_hd__fill_2
XFILLER_39_679 VGND VGND VPWR VPWR sky130_fd_sc_hd__decap_3
XFILLER_54_616 VGND VGND VPWR VPWR sky130_fd_sc_hd__decap_3
XFILLER_66_487 VGND VGND VPWR VPWR sky130_fd_sc_hd__decap_3
XFILLER_81_413 VGND VGND VPWR VPWR sky130_fd_sc_hd__decap_3
X_6952_ clkload2/A _6952_/D VGND VGND VPWR VPWR _6952_/Q sky130_fd_sc_hd__dfxtp_2
XFILLER_34_351 VGND VGND VPWR VPWR sky130_fd_sc_hd__decap_3
XFILLER_62_660 VGND VGND VPWR VPWR sky130_fd_sc_hd__decap_3
X_6883_ _7406_/CLK _6883_/D VGND VGND VPWR VPWR _6883_/Q sky130_fd_sc_hd__dfxtp_2
XFILLER_34_362 VGND VGND VPWR VPWR sky130_fd_sc_hd__fill_2
XFILLER_22_546 VGND VGND VPWR VPWR sky130_fd_sc_hd__fill_2
XFILLER_108_607 VGND VGND VPWR VPWR sky130_fd_sc_hd__decap_3
X_4716_ _4606_/Y _4664_/X _4695_/X _7008_/D _4997_/A1 VGND VGND VPWR VPWR _4716_/X
+ sky130_fd_sc_hd__a32o_2
XFILLER_30_38 VGND VGND VPWR VPWR sky130_fd_sc_hd__decap_3
X_4647_ _4813_/A _4827_/A _4647_/C _4787_/A VGND VGND VPWR VPWR _4647_/X sky130_fd_sc_hd__and4_2
X_7366_ _7402_/CLK _7366_/D _6646_/Y VGND VGND VPWR VPWR _7366_/Q sky130_fd_sc_hd__dfrtp_2
Xhold720 _6791_/Q VGND VGND VPWR VPWR _6791_/D sky130_fd_sc_hd__dlygate4sd3_1
XFILLER_100_9 VGND VGND VPWR VPWR sky130_fd_sc_hd__decap_3
XFILLER_116_651 VGND VGND VPWR VPWR sky130_fd_sc_hd__decap_3
XFILLER_116_673 VGND VGND VPWR VPWR sky130_fd_sc_hd__decap_3
XFILLER_1_417 VGND VGND VPWR VPWR sky130_fd_sc_hd__decap_3
Xhold731 _6748_/Q VGND VGND VPWR VPWR _6748_/D sky130_fd_sc_hd__dlygate4sd3_1
Xhold742 _6768_/Q VGND VGND VPWR VPWR _6768_/D sky130_fd_sc_hd__dlygate4sd3_1
Xhold753 _6816_/Q VGND VGND VPWR VPWR _6816_/D sky130_fd_sc_hd__dlygate4sd3_1
Xhold764 _6756_/Q VGND VGND VPWR VPWR _6756_/D sky130_fd_sc_hd__dlygate4sd3_1
X_6317_ _6562_/A VGND VGND VPWR VPWR _6317_/Y sky130_fd_sc_hd__inv_2
XTAP_TAPCELL_ROW_73_1123 VGND VPWR sky130_fd_sc_hd__tapvpwrvgnd_1
XFILLER_115_161 VGND VGND VPWR VPWR sky130_fd_sc_hd__decap_3
XFILLER_115_172 VGND VGND VPWR VPWR sky130_fd_sc_hd__decap_3
XFILLER_89_524 VGND VGND VPWR VPWR sky130_fd_sc_hd__decap_3
X_7297_ _7397_/CLK _7297_/D _6577_/Y VGND VGND VPWR VPWR _7297_/Q sky130_fd_sc_hd__dfrtp_2
Xhold775 _6741_/Q VGND VGND VPWR VPWR _6741_/D sky130_fd_sc_hd__dlygate4sd3_1
Xhold786 _6945_/Q VGND VGND VPWR VPWR _6945_/D sky130_fd_sc_hd__dlygate4sd3_1
Xhold797 _6817_/Q VGND VGND VPWR VPWR _6817_/D sky130_fd_sc_hd__dlygate4sd3_1
XFILLER_103_367 VGND VGND VPWR VPWR sky130_fd_sc_hd__decap_3
XFILLER_39_36 VGND VGND VPWR VPWR sky130_fd_sc_hd__decap_3
XFILLER_29_134 VGND VGND VPWR VPWR sky130_fd_sc_hd__fill_1
XFILLER_57_443 VGND VGND VPWR VPWR sky130_fd_sc_hd__decap_3
XFILLER_69_281 VGND VGND VPWR VPWR sky130_fd_sc_hd__decap_3
XFILLER_55_24 VGND VGND VPWR VPWR sky130_fd_sc_hd__decap_3
XFILLER_72_402 VGND VGND VPWR VPWR sky130_fd_sc_hd__decap_3
XTAP_TAPCELL_ROW_4_299 VGND VPWR sky130_fd_sc_hd__tapvpwrvgnd_1
XFILLER_44_115 VGND VGND VPWR VPWR sky130_fd_sc_hd__decap_3
XFILLER_55_57 VGND VGND VPWR VPWR sky130_fd_sc_hd__decap_3
XFILLER_72_424 VGND VGND VPWR VPWR sky130_fd_sc_hd__decap_3
XFILLER_25_340 VGND VGND VPWR VPWR sky130_fd_sc_hd__decap_3
XFILLER_60_619 VGND VGND VPWR VPWR sky130_fd_sc_hd__decap_3
XFILLER_111_41 VGND VGND VPWR VPWR sky130_fd_sc_hd__decap_3
XFILLER_111_63 VGND VGND VPWR VPWR sky130_fd_sc_hd__decap_3
XFILLER_13_502 VGND VGND VPWR VPWR sky130_fd_sc_hd__fill_2
XFILLER_53_671 VGND VGND VPWR VPWR sky130_fd_sc_hd__fill_1
XFILLER_53_682 VGND VGND VPWR VPWR sky130_fd_sc_hd__fill_2
XFILLER_71_12 VGND VGND VPWR VPWR sky130_fd_sc_hd__decap_3
XTAP_TAPCELL_ROW_84_1263 VGND VPWR sky130_fd_sc_hd__tapvpwrvgnd_1
XFILLER_111_96 VGND VGND VPWR VPWR sky130_fd_sc_hd__decap_3
XFILLER_40_321 VGND VGND VPWR VPWR sky130_fd_sc_hd__decap_3
XFILLER_52_181 VGND VGND VPWR VPWR sky130_fd_sc_hd__decap_3
XTAP_TAPCELL_ROW_23_530 VGND VPWR sky130_fd_sc_hd__tapvpwrvgnd_1
XFILLER_40_365 VGND VGND VPWR VPWR sky130_fd_sc_hd__fill_2
XTAP_TAPCELL_ROW_51_861 VGND VPWR sky130_fd_sc_hd__tapvpwrvgnd_1
XFILLER_107_662 VGND VGND VPWR VPWR sky130_fd_sc_hd__decap_3
XFILLER_107_673 VGND VGND VPWR VPWR sky130_fd_sc_hd__decap_3
XFILLER_20_82 VGND VGND VPWR VPWR sky130_fd_sc_hd__fill_2
XFILLER_4_277 VGND VGND VPWR VPWR sky130_fd_sc_hd__decap_3
XFILLER_96_20 VGND VGND VPWR VPWR sky130_fd_sc_hd__decap_3
XTAP_TAPCELL_ROW_95_1392 VGND VPWR sky130_fd_sc_hd__tapvpwrvgnd_1
XFILLER_106_194 VGND VGND VPWR VPWR sky130_fd_sc_hd__fill_2
XFILLER_96_53 VGND VGND VPWR VPWR sky130_fd_sc_hd__decap_3
XFILLER_0_461 VGND VGND VPWR VPWR sky130_fd_sc_hd__decap_3
XFILLER_48_410 VGND VGND VPWR VPWR sky130_fd_sc_hd__decap_3
XFILLER_95_549 VGND VGND VPWR VPWR sky130_fd_sc_hd__decap_3
XFILLER_48_421 VGND VGND VPWR VPWR sky130_fd_sc_hd__fill_1
XTAP_TAPCELL_ROW_59_961 VGND VPWR sky130_fd_sc_hd__tapvpwrvgnd_1
XFILLER_35_137 VGND VGND VPWR VPWR sky130_fd_sc_hd__fill_1
XFILLER_63_424 VGND VGND VPWR VPWR sky130_fd_sc_hd__decap_3
XFILLER_63_435 VGND VGND VPWR VPWR sky130_fd_sc_hd__decap_3
XFILLER_75_284 VGND VGND VPWR VPWR sky130_fd_sc_hd__decap_3
Xplace402 _4503_/S VGND VGND VPWR VPWR _4528_/B sky130_fd_sc_hd__buf_2
Xplace413 _4196_/A2 VGND VGND VPWR VPWR _4354_/B1 sky130_fd_sc_hd__buf_2
XFILLER_51_608 VGND VGND VPWR VPWR sky130_fd_sc_hd__decap_3
XFILLER_90_265 VGND VGND VPWR VPWR sky130_fd_sc_hd__decap_3
Xplace424 _3964_/S VGND VGND VPWR VPWR _3968_/S sky130_fd_sc_hd__buf_2
Xplace435 _3344_/Y VGND VGND VPWR VPWR _4677_/B sky130_fd_sc_hd__buf_2
Xplace446 _3318_/B VGND VGND VPWR VPWR _4331_/A2 sky130_fd_sc_hd__buf_2
XFILLER_44_682 VGND VGND VPWR VPWR sky130_fd_sc_hd__decap_3
XFILLER_50_129 VGND VGND VPWR VPWR sky130_fd_sc_hd__decap_3
XFILLER_90_298 VGND VGND VPWR VPWR sky130_fd_sc_hd__decap_3
Xplace457 _6981_/Q VGND VGND VPWR VPWR _3327_/A sky130_fd_sc_hd__buf_2
XFILLER_16_395 VGND VGND VPWR VPWR sky130_fd_sc_hd__decap_3
X_3880_ _3714_/X _3877_/X _3879_/X _3735_/X VGND VGND VPWR VPWR _3880_/X sky130_fd_sc_hd__a22o_2
XFILLER_77_3 VGND VGND VPWR VPWR sky130_fd_sc_hd__decap_3
X_4501_ _4501_/A0 _4567_/A _4501_/S VGND VGND VPWR VPWR _7329_/D sky130_fd_sc_hd__mux2_2
X_7220_ clkload5/A _7220_/D _6500_/Y VGND VGND VPWR VPWR _7220_/Q sky130_fd_sc_hd__dfrtp_2
X_4432_ _7079_/Q _4432_/A2 _4432_/B1 _4431_/X VGND VGND VPWR VPWR _4440_/A sky130_fd_sc_hd__o211ai_2
XFILLER_104_109 VGND VGND VPWR VPWR sky130_fd_sc_hd__decap_3
XFILLER_6_62 VGND VGND VPWR VPWR sky130_fd_sc_hd__decap_3
XFILLER_113_632 VGND VGND VPWR VPWR sky130_fd_sc_hd__decap_3
XFILLER_116_19 VGND VGND VPWR VPWR sky130_fd_sc_hd__fill_1
X_7151_ _7360_/CLK _7151_/D _6431_/Y VGND VGND VPWR VPWR _7151_/Q sky130_fd_sc_hd__dfrtp_2
X_4363_ _4619_/B VGND VGND VPWR VPWR _4369_/A sky130_fd_sc_hd__inv_2
XFILLER_113_665 VGND VGND VPWR VPWR sky130_fd_sc_hd__decap_3
XFILLER_113_676 VGND VGND VPWR VPWR sky130_fd_sc_hd__decap_3
X_7082_ _7234_/CLK _7082_/D _6362_/Y VGND VGND VPWR VPWR _7082_/Q sky130_fd_sc_hd__dfrtp_2
X_4294_ _4612_/A _4612_/B VGND VGND VPWR VPWR _5113_/A sky130_fd_sc_hd__xor2_2
X_3314_ _4467_/A _4467_/B VGND VGND VPWR VPWR _5647_/A sky130_fd_sc_hd__or2_2
XFILLER_98_365 VGND VGND VPWR VPWR sky130_fd_sc_hd__decap_3
XFILLER_98_343 VGND VGND VPWR VPWR sky130_fd_sc_hd__decap_3
XFILLER_112_153 VGND VGND VPWR VPWR sky130_fd_sc_hd__decap_3
XFILLER_112_186 VGND VGND VPWR VPWR sky130_fd_sc_hd__decap_3
XFILLER_58_218 VGND VGND VPWR VPWR sky130_fd_sc_hd__decap_3
XFILLER_86_516 VGND VGND VPWR VPWR sky130_fd_sc_hd__fill_1
XFILLER_86_527 VGND VGND VPWR VPWR sky130_fd_sc_hd__decap_3
XFILLER_112_197 VGND VGND VPWR VPWR sky130_fd_sc_hd__decap_3
XFILLER_39_443 VGND VGND VPWR VPWR sky130_fd_sc_hd__decap_3
XFILLER_27_627 VGND VGND VPWR VPWR sky130_fd_sc_hd__decap_3
XFILLER_39_476 VGND VGND VPWR VPWR sky130_fd_sc_hd__decap_3
XFILLER_66_240 VGND VGND VPWR VPWR sky130_fd_sc_hd__decap_3
XFILLER_66_262 VGND VGND VPWR VPWR sky130_fd_sc_hd__decap_3
XFILLER_54_413 VGND VGND VPWR VPWR sky130_fd_sc_hd__decap_3
XFILLER_54_424 VGND VGND VPWR VPWR sky130_fd_sc_hd__decap_3
XTAP_TAPCELL_ROW_1_258 VGND VPWR sky130_fd_sc_hd__tapvpwrvgnd_1
XTAP_TAPCELL_ROW_107_1539 VGND VPWR sky130_fd_sc_hd__tapvpwrvgnd_1
X_6935_ _7005_/CLK _6935_/D VGND VGND VPWR VPWR _6935_/Q sky130_fd_sc_hd__dfxtp_2
XTAP_TAPCELL_ROW_1_269 VGND VPWR sky130_fd_sc_hd__tapvpwrvgnd_1
XFILLER_34_170 VGND VGND VPWR VPWR sky130_fd_sc_hd__decap_3
XFILLER_35_682 VGND VGND VPWR VPWR sky130_fd_sc_hd__fill_2
XTAP_TAPCELL_ROW_37_699 VGND VPWR sky130_fd_sc_hd__tapvpwrvgnd_1
XFILLER_22_321 VGND VGND VPWR VPWR sky130_fd_sc_hd__decap_3
XFILLER_50_630 VGND VGND VPWR VPWR sky130_fd_sc_hd__decap_3
X_6866_ _7383_/CLK _6866_/D VGND VGND VPWR VPWR _6866_/Q sky130_fd_sc_hd__dfxtp_2
XFILLER_22_365 VGND VGND VPWR VPWR sky130_fd_sc_hd__decap_3
XFILLER_22_376 VGND VGND VPWR VPWR sky130_fd_sc_hd__fill_1
XFILLER_50_663 VGND VGND VPWR VPWR sky130_fd_sc_hd__decap_3
X_6797_ _7005_/CLK _6797_/D VGND VGND VPWR VPWR _6797_/Q sky130_fd_sc_hd__dfxtp_2
XFILLER_41_26 VGND VGND VPWR VPWR sky130_fd_sc_hd__decap_3
XFILLER_108_404 VGND VGND VPWR VPWR sky130_fd_sc_hd__decap_3
XFILLER_104_610 VGND VGND VPWR VPWR sky130_fd_sc_hd__decap_3
XFILLER_116_492 VGND VGND VPWR VPWR sky130_fd_sc_hd__fill_1
X_7349_ clkload9/A _7349_/D _6629_/Y VGND VGND VPWR VPWR _7349_/Q sky130_fd_sc_hd__dfrtp_2
XTAP_TAPCELL_ROW_9_358 VGND VPWR sky130_fd_sc_hd__tapvpwrvgnd_1
XFILLER_9_6 VGND VGND VPWR VPWR sky130_fd_sc_hd__decap_3
XFILLER_103_131 VGND VGND VPWR VPWR sky130_fd_sc_hd__fill_2
XFILLER_103_142 VGND VGND VPWR VPWR sky130_fd_sc_hd__decap_3
XFILLER_104_643 VGND VGND VPWR VPWR sky130_fd_sc_hd__fill_1
XFILLER_104_654 VGND VGND VPWR VPWR sky130_fd_sc_hd__decap_3
XFILLER_1_236 VGND VGND VPWR VPWR sky130_fd_sc_hd__fill_2
XFILLER_77_505 VGND VGND VPWR VPWR sky130_fd_sc_hd__decap_3
XFILLER_89_343 VGND VGND VPWR VPWR sky130_fd_sc_hd__decap_3
XFILLER_89_365 VGND VGND VPWR VPWR sky130_fd_sc_hd__fill_1
Xhold583 _6944_/Q VGND VGND VPWR VPWR _6944_/D sky130_fd_sc_hd__dlygate4sd3_1
Xhold594 _6914_/Q VGND VGND VPWR VPWR _6914_/D sky130_fd_sc_hd__dlygate4sd3_1
XFILLER_104_687 VGND VGND VPWR VPWR sky130_fd_sc_hd__decap_3
XFILLER_106_41 VGND VGND VPWR VPWR sky130_fd_sc_hd__decap_3
XFILLER_89_387 VGND VGND VPWR VPWR sky130_fd_sc_hd__decap_3
XFILLER_106_74 VGND VGND VPWR VPWR sky130_fd_sc_hd__decap_3
XFILLER_66_12 VGND VGND VPWR VPWR sky130_fd_sc_hd__decap_3
XFILLER_66_45 VGND VGND VPWR VPWR sky130_fd_sc_hd__decap_3
XFILLER_18_616 VGND VGND VPWR VPWR sky130_fd_sc_hd__decap_3
XFILLER_45_402 VGND VGND VPWR VPWR sky130_fd_sc_hd__decap_3
XFILLER_57_251 VGND VGND VPWR VPWR sky130_fd_sc_hd__decap_3
XFILLER_66_78 VGND VGND VPWR VPWR sky130_fd_sc_hd__decap_3
XFILLER_92_519 VGND VGND VPWR VPWR sky130_fd_sc_hd__decap_3
XFILLER_45_435 VGND VGND VPWR VPWR sky130_fd_sc_hd__decap_3
XFILLER_57_284 VGND VGND VPWR VPWR sky130_fd_sc_hd__decap_3
XTAP_TAPCELL_ROW_56_920 VGND VPWR sky130_fd_sc_hd__tapvpwrvgnd_1
XFILLER_17_148 VGND VGND VPWR VPWR sky130_fd_sc_hd__decap_3
XFILLER_72_243 VGND VGND VPWR VPWR sky130_fd_sc_hd__decap_3
XFILLER_72_265 VGND VGND VPWR VPWR sky130_fd_sc_hd__decap_3
XFILLER_82_44 VGND VGND VPWR VPWR sky130_fd_sc_hd__decap_3
XFILLER_82_77 VGND VGND VPWR VPWR sky130_fd_sc_hd__decap_3
XFILLER_82_99 VGND VGND VPWR VPWR sky130_fd_sc_hd__decap_3
XFILLER_15_60 VGND VGND VPWR VPWR sky130_fd_sc_hd__decap_3
XFILLER_40_151 VGND VGND VPWR VPWR sky130_fd_sc_hd__decap_3
XFILLER_41_685 VGND VGND VPWR VPWR sky130_fd_sc_hd__decap_3
XFILLER_13_387 VGND VGND VPWR VPWR sky130_fd_sc_hd__decap_3
XFILLER_40_184 VGND VGND VPWR VPWR sky130_fd_sc_hd__decap_3
XTAP_TAPCELL_ROW_97_1421 VGND VPWR sky130_fd_sc_hd__tapvpwrvgnd_1
XTAP_TAPCELL_ROW_97_1410 VGND VPWR sky130_fd_sc_hd__tapvpwrvgnd_1
XFILLER_31_81 VGND VGND VPWR VPWR sky130_fd_sc_hd__decap_3
XFILLER_5_542 VGND VGND VPWR VPWR sky130_fd_sc_hd__fill_1
XFILLER_5_564 VGND VGND VPWR VPWR sky130_fd_sc_hd__fill_2
XFILLER_107_492 VGND VGND VPWR VPWR sky130_fd_sc_hd__decap_3
XFILLER_110_613 VGND VGND VPWR VPWR sky130_fd_sc_hd__decap_3
XFILLER_95_324 VGND VGND VPWR VPWR sky130_fd_sc_hd__decap_3
XFILLER_110_657 VGND VGND VPWR VPWR sky130_fd_sc_hd__decap_3
XFILLER_95_346 VGND VGND VPWR VPWR sky130_fd_sc_hd__decap_3
XFILLER_95_368 VGND VGND VPWR VPWR sky130_fd_sc_hd__decap_3
XFILLER_48_273 VGND VGND VPWR VPWR sky130_fd_sc_hd__decap_3
XFILLER_17_671 VGND VGND VPWR VPWR sky130_fd_sc_hd__fill_1
XFILLER_51_405 VGND VGND VPWR VPWR sky130_fd_sc_hd__decap_3
XFILLER_63_276 VGND VGND VPWR VPWR sky130_fd_sc_hd__decap_3
XFILLER_63_287 VGND VGND VPWR VPWR sky130_fd_sc_hd__fill_2
X_4981_ _6992_/Q _5001_/A VGND VGND VPWR VPWR _6992_/D sky130_fd_sc_hd__xor2_2
XFILLER_32_641 VGND VGND VPWR VPWR sky130_fd_sc_hd__decap_3
XFILLER_51_449 VGND VGND VPWR VPWR sky130_fd_sc_hd__fill_1
Xclkbuf_leaf_43_clk clkbuf_3_0__f_clk/X VGND VGND VPWR VPWR clkload4/A sky130_fd_sc_hd__clkbuf_16
Xplace298 _3640_/X VGND VGND VPWR VPWR _3665_/B sky130_fd_sc_hd__buf_2
Xplace287 _3887_/A2 VGND VGND VPWR VPWR _3889_/B1 sky130_fd_sc_hd__buf_2
Xplace276 _3879_/A2 VGND VGND VPWR VPWR _3884_/A2 sky130_fd_sc_hd__buf_2
Xplace265 _5660_/A VGND VGND VPWR VPWR _3682_/A sky130_fd_sc_hd__buf_2
X_6720_ _6975_/CLK _6720_/D VGND VGND VPWR VPWR _6720_/Q sky130_fd_sc_hd__dfxtp_2
XTAP_TAPCELL_ROW_34_658 VGND VPWR sky130_fd_sc_hd__tapvpwrvgnd_1
X_6651_ _6651_/A VGND VGND VPWR VPWR _6651_/Y sky130_fd_sc_hd__inv_2
X_3863_ _6697_/Q _3925_/A2 _3925_/B1 _6875_/Q _3862_/X VGND VGND VPWR VPWR _3863_/X
+ sky130_fd_sc_hd__a221o_2
XFILLER_31_184 VGND VGND VPWR VPWR sky130_fd_sc_hd__decap_3
X_6582_ _6675_/A VGND VGND VPWR VPWR _6582_/Y sky130_fd_sc_hd__inv_2
X_5602_ _5602_/A _5634_/B VGND VGND VPWR VPWR _7026_/D sky130_fd_sc_hd__and2_2
X_3794_ _6774_/Q _3879_/A2 _3889_/A2 _6762_/Q _3793_/X VGND VGND VPWR VPWR _3794_/X
+ sky130_fd_sc_hd__a221o_2
XFILLER_11_18 VGND VGND VPWR VPWR sky130_fd_sc_hd__decap_3
X_7203_ _7334_/CLK _7203_/D _6483_/Y VGND VGND VPWR VPWR _7203_/Q sky130_fd_sc_hd__dfrtp_2
X_4415_ _7400_/Q _4419_/B1 _4434_/B1 _7144_/Q _4414_/X VGND VGND VPWR VPWR _4415_/X
+ sky130_fd_sc_hd__a221o_2
X_7134_ _7294_/CLK _7134_/D _6414_/Y VGND VGND VPWR VPWR _7134_/Q sky130_fd_sc_hd__dfrtp_2
X_4346_ _7321_/Q _4471_/S _3380_/Y _7353_/Q VGND VGND VPWR VPWR _4346_/X sky130_fd_sc_hd__a22o_2
XFILLER_99_641 VGND VGND VPWR VPWR sky130_fd_sc_hd__decap_3
XFILLER_101_613 VGND VGND VPWR VPWR sky130_fd_sc_hd__decap_3
XTAP_TAPCELL_ROW_6_328 VGND VPWR sky130_fd_sc_hd__tapvpwrvgnd_1
XFILLER_99_685 VGND VGND VPWR VPWR sky130_fd_sc_hd__decap_3
XFILLER_101_635 VGND VGND VPWR VPWR sky130_fd_sc_hd__decap_3
XFILLER_86_346 VGND VGND VPWR VPWR sky130_fd_sc_hd__decap_3
X_7065_ clkload7/A _7065_/D _6345_/Y VGND VGND VPWR VPWR _7065_/Q sky130_fd_sc_hd__dfrtp_2
X_4277_ _5003_/A _4620_/C VGND VGND VPWR VPWR _4277_/Y sky130_fd_sc_hd__nor2_2
XFILLER_101_668 VGND VGND VPWR VPWR sky130_fd_sc_hd__decap_3
XFILLER_101_679 VGND VGND VPWR VPWR sky130_fd_sc_hd__decap_3
XFILLER_36_15 VGND VGND VPWR VPWR sky130_fd_sc_hd__decap_3
XFILLER_39_284 VGND VGND VPWR VPWR sky130_fd_sc_hd__decap_3
XFILLER_54_221 VGND VGND VPWR VPWR sky130_fd_sc_hd__decap_3
XFILLER_82_541 VGND VGND VPWR VPWR sky130_fd_sc_hd__fill_1
XFILLER_42_416 VGND VGND VPWR VPWR sky130_fd_sc_hd__decap_3
XFILLER_54_265 VGND VGND VPWR VPWR sky130_fd_sc_hd__decap_3
XFILLER_54_287 VGND VGND VPWR VPWR sky130_fd_sc_hd__decap_3
XFILLER_82_574 VGND VGND VPWR VPWR sky130_fd_sc_hd__decap_3
XTAP_TAPCELL_ROW_68_1066 VGND VPWR sky130_fd_sc_hd__tapvpwrvgnd_1
XFILLER_14_129 VGND VGND VPWR VPWR sky130_fd_sc_hd__decap_3
XFILLER_42_438 VGND VGND VPWR VPWR sky130_fd_sc_hd__fill_2
XFILLER_52_14 VGND VGND VPWR VPWR sky130_fd_sc_hd__decap_3
Xclkbuf_leaf_34_clk clkbuf_3_2__f_clk/X VGND VGND VPWR VPWR _6975_/CLK sky130_fd_sc_hd__clkbuf_16
X_6918_ _7386_/CLK _6918_/D VGND VGND VPWR VPWR _6918_/Q sky130_fd_sc_hd__dfxtp_2
XTAP_TAPCELL_ROW_81_1222 VGND VPWR sky130_fd_sc_hd__tapvpwrvgnd_1
XFILLER_23_652 VGND VGND VPWR VPWR sky130_fd_sc_hd__fill_2
XFILLER_52_47 VGND VGND VPWR VPWR sky130_fd_sc_hd__fill_1
X_6849_ _6946_/CLK _6849_/D VGND VGND VPWR VPWR _6849_/Q sky130_fd_sc_hd__dfxtp_2
XFILLER_10_324 VGND VGND VPWR VPWR sky130_fd_sc_hd__decap_3
XFILLER_52_58 VGND VGND VPWR VPWR sky130_fd_sc_hd__decap_3
XFILLER_108_212 VGND VGND VPWR VPWR sky130_fd_sc_hd__decap_3
XFILLER_108_267 VGND VGND VPWR VPWR sky130_fd_sc_hd__fill_1
XFILLER_108_289 VGND VGND VPWR VPWR sky130_fd_sc_hd__decap_3
XTAP_TAPCELL_ROW_79_1195 VGND VPWR sky130_fd_sc_hd__tapvpwrvgnd_1
XFILLER_7_3 VGND VGND VPWR VPWR sky130_fd_sc_hd__decap_3
XTAP_TAPCELL_ROW_92_1351 VGND VPWR sky130_fd_sc_hd__tapvpwrvgnd_1
XFILLER_104_462 VGND VGND VPWR VPWR sky130_fd_sc_hd__fill_1
XFILLER_2_589 VGND VGND VPWR VPWR sky130_fd_sc_hd__decap_3
XFILLER_89_162 VGND VGND VPWR VPWR sky130_fd_sc_hd__decap_3
XFILLER_77_88 VGND VGND VPWR VPWR sky130_fd_sc_hd__fill_1
XFILLER_77_379 VGND VGND VPWR VPWR sky130_fd_sc_hd__fill_1
XFILLER_100_690 VGND VGND VPWR VPWR sky130_fd_sc_hd__fill_2
XFILLER_92_338 VGND VGND VPWR VPWR sky130_fd_sc_hd__fill_2
XFILLER_18_457 VGND VGND VPWR VPWR sky130_fd_sc_hd__decap_3
XFILLER_45_243 VGND VGND VPWR VPWR sky130_fd_sc_hd__decap_3
XFILLER_93_43 VGND VGND VPWR VPWR sky130_fd_sc_hd__fill_1
Xhold1080 _7275_/Q VGND VGND VPWR VPWR _4772_/A0 sky130_fd_sc_hd__dlygate4sd3_1
Xhold1091 _7378_/Q VGND VGND VPWR VPWR _3915_/A0 sky130_fd_sc_hd__dlygate4sd3_1
XFILLER_33_427 VGND VGND VPWR VPWR sky130_fd_sc_hd__fill_1
XFILLER_45_287 VGND VGND VPWR VPWR sky130_fd_sc_hd__decap_3
XFILLER_93_76 VGND VGND VPWR VPWR sky130_fd_sc_hd__decap_3
XFILLER_14_641 VGND VGND VPWR VPWR sky130_fd_sc_hd__decap_3
XFILLER_33_449 VGND VGND VPWR VPWR sky130_fd_sc_hd__fill_2
XFILLER_60_224 VGND VGND VPWR VPWR sky130_fd_sc_hd__decap_3
XFILLER_60_246 VGND VGND VPWR VPWR sky130_fd_sc_hd__decap_3
Xclkbuf_leaf_25_clk clkload0/A VGND VGND VPWR VPWR _6944_/CLK sky130_fd_sc_hd__clkbuf_16
XFILLER_60_268 VGND VGND VPWR VPWR sky130_fd_sc_hd__decap_3
XTAP_TAPCELL_ROW_31_628 VGND VPWR sky130_fd_sc_hd__tapvpwrvgnd_1
XFILLER_9_122 VGND VGND VPWR VPWR sky130_fd_sc_hd__decap_3
XFILLER_9_111 VGND VGND VPWR VPWR sky130_fd_sc_hd__fill_1
XFILLER_42_91 VGND VGND VPWR VPWR sky130_fd_sc_hd__decap_3
XFILLER_61_6 VGND VGND VPWR VPWR sky130_fd_sc_hd__decap_3
XTAP_TAPCELL_ROW_11_385 VGND VPWR sky130_fd_sc_hd__tapvpwrvgnd_1
XFILLER_114_215 VGND VGND VPWR VPWR sky130_fd_sc_hd__decap_3
XFILLER_5_372 VGND VGND VPWR VPWR sky130_fd_sc_hd__decap_3
XFILLER_114_248 VGND VGND VPWR VPWR sky130_fd_sc_hd__decap_3
XFILLER_114_259 VGND VGND VPWR VPWR sky130_fd_sc_hd__decap_3
X_4200_ _4634_/D _4381_/A VGND VGND VPWR VPWR _4200_/X sky130_fd_sc_hd__or2_2
XFILLER_3_30 VGND VGND VPWR VPWR sky130_fd_sc_hd__decap_3
XFILLER_96_611 VGND VGND VPWR VPWR sky130_fd_sc_hd__decap_3
XFILLER_110_410 VGND VGND VPWR VPWR sky130_fd_sc_hd__decap_3
XFILLER_110_421 VGND VGND VPWR VPWR sky130_fd_sc_hd__decap_3
XFILLER_3_63 VGND VGND VPWR VPWR sky130_fd_sc_hd__decap_3
XFILLER_95_110 VGND VGND VPWR VPWR sky130_fd_sc_hd__fill_2
X_4131_ _7267_/Q _4418_/A2 _4128_/X _4130_/X VGND VGND VPWR VPWR _4131_/X sky130_fd_sc_hd__a211o_2
XFILLER_3_96 VGND VGND VPWR VPWR sky130_fd_sc_hd__decap_3
XFILLER_56_519 VGND VGND VPWR VPWR sky130_fd_sc_hd__fill_1
XFILLER_68_368 VGND VGND VPWR VPWR sky130_fd_sc_hd__decap_3
XFILLER_95_154 VGND VGND VPWR VPWR sky130_fd_sc_hd__fill_2
XFILLER_96_666 VGND VGND VPWR VPWR sky130_fd_sc_hd__decap_3
X_4062_ _7026_/Q _4437_/A2 _3945_/S _7212_/Q _4061_/X VGND VGND VPWR VPWR _4062_/X
+ sky130_fd_sc_hd__a221o_2
XTAP_TAPCELL_ROW_39_717 VGND VPWR sky130_fd_sc_hd__tapvpwrvgnd_1
XFILLER_95_198 VGND VGND VPWR VPWR sky130_fd_sc_hd__decap_3
XFILLER_36_221 VGND VGND VPWR VPWR sky130_fd_sc_hd__decap_3
XFILLER_24_416 VGND VGND VPWR VPWR sky130_fd_sc_hd__decap_3
XFILLER_24_427 VGND VGND VPWR VPWR sky130_fd_sc_hd__fill_1
XFILLER_91_371 VGND VGND VPWR VPWR sky130_fd_sc_hd__decap_3
XTAP_TAPCELL_ROW_19_474 VGND VPWR sky130_fd_sc_hd__tapvpwrvgnd_1
XFILLER_36_298 VGND VGND VPWR VPWR sky130_fd_sc_hd__decap_3
XFILLER_91_382 VGND VGND VPWR VPWR sky130_fd_sc_hd__decap_3
XFILLER_91_393 VGND VGND VPWR VPWR sky130_fd_sc_hd__decap_3
Xclkbuf_leaf_16_clk clkload1/A VGND VGND VPWR VPWR _7310_/CLK sky130_fd_sc_hd__clkbuf_16
X_4964_ _4964_/A1 _4961_/X _6994_/D _4997_/A1 VGND VGND VPWR VPWR _4964_/X sky130_fd_sc_hd__a22o_2
XTAP_TAPCELL_ROW_19_485 VGND VPWR sky130_fd_sc_hd__tapvpwrvgnd_1
XFILLER_51_279 VGND VGND VPWR VPWR sky130_fd_sc_hd__fill_1
X_6703_ _7383_/CLK _6703_/D VGND VGND VPWR VPWR _6703_/Q sky130_fd_sc_hd__dfxtp_2
X_3915_ _3915_/A0 _3914_/X _5151_/A VGND VGND VPWR VPWR _7378_/D sky130_fd_sc_hd__mux2_2
X_4895_ _6997_/Q _5622_/B _4909_/B VGND VGND VPWR VPWR _4896_/B sky130_fd_sc_hd__a21o_2
X_6634_ _6634_/A VGND VGND VPWR VPWR _6634_/Y sky130_fd_sc_hd__inv_2
X_3846_ _6964_/Q _3906_/A2 _3907_/A2 _6952_/Q VGND VGND VPWR VPWR _3846_/X sky130_fd_sc_hd__a22o_2
X_6565_ _6599_/A VGND VGND VPWR VPWR _6565_/Y sky130_fd_sc_hd__inv_2
X_3777_ _6972_/Q _3889_/B1 _3665_/X _6722_/Q _3776_/X VGND VGND VPWR VPWR _3777_/X
+ sky130_fd_sc_hd__a221o_2
X_6496_ _6562_/A VGND VGND VPWR VPWR _6496_/Y sky130_fd_sc_hd__inv_2
XTAP_TAPCELL_ROW_115_1627 VGND VPWR sky130_fd_sc_hd__tapvpwrvgnd_1
Xoutput496 _5647_/Y VGND VGND VPWR VPWR instruction_out[11] sky130_fd_sc_hd__clkdlybuf4s25_1
Xoutput485 _3634_/Y VGND VGND VPWR VPWR alu_result_out[2] sky130_fd_sc_hd__clkdlybuf4s25_1
Xoutput474 _5659_/B VGND VGND VPWR VPWR alu_result_out[1] sky130_fd_sc_hd__clkdlybuf4s25_1
Xoutput463 _5650_/Y VGND VGND VPWR VPWR alu_result_out[0] sky130_fd_sc_hd__clkdlybuf4s25_1
XFILLER_101_410 VGND VGND VPWR VPWR sky130_fd_sc_hd__decap_3
XFILLER_101_432 VGND VGND VPWR VPWR sky130_fd_sc_hd__decap_3
XFILLER_113_270 VGND VGND VPWR VPWR sky130_fd_sc_hd__decap_3
XFILLER_113_281 VGND VGND VPWR VPWR sky130_fd_sc_hd__decap_3
XFILLER_59_324 VGND VGND VPWR VPWR sky130_fd_sc_hd__decap_3
XFILLER_87_644 VGND VGND VPWR VPWR sky130_fd_sc_hd__decap_3
X_7117_ _7310_/CLK _7117_/D _6397_/Y VGND VGND VPWR VPWR _7117_/Q sky130_fd_sc_hd__dfrtp_2
X_4329_ _4362_/C _4362_/A _4362_/B VGND VGND VPWR VPWR _4330_/B sky130_fd_sc_hd__and3b_2
XFILLER_86_154 VGND VGND VPWR VPWR sky130_fd_sc_hd__decap_3
XFILLER_87_688 VGND VGND VPWR VPWR sky130_fd_sc_hd__decap_3
X_7048_ _7334_/CLK _7048_/D _6328_/Y VGND VGND VPWR VPWR _7048_/Q sky130_fd_sc_hd__dfrtp_2
XFILLER_47_69 VGND VGND VPWR VPWR sky130_fd_sc_hd__decap_3
XPHY_EDGE_ROW_114_Right_114 VGND VGND VPWR VPWR sky130_fd_sc_hd__decap_3
XFILLER_27_221 VGND VGND VPWR VPWR sky130_fd_sc_hd__decap_3
XFILLER_27_243 VGND VGND VPWR VPWR sky130_fd_sc_hd__decap_3
XFILLER_55_541 VGND VGND VPWR VPWR sky130_fd_sc_hd__fill_2
XFILLER_103_75 VGND VGND VPWR VPWR sky130_fd_sc_hd__decap_3
XFILLER_15_405 VGND VGND VPWR VPWR sky130_fd_sc_hd__fill_1
XFILLER_15_427 VGND VGND VPWR VPWR sky130_fd_sc_hd__decap_3
XFILLER_55_585 VGND VGND VPWR VPWR sky130_fd_sc_hd__decap_3
XFILLER_15_449 VGND VGND VPWR VPWR sky130_fd_sc_hd__fill_1
XFILLER_27_287 VGND VGND VPWR VPWR sky130_fd_sc_hd__decap_3
XFILLER_42_213 VGND VGND VPWR VPWR sky130_fd_sc_hd__decap_3
XFILLER_42_246 VGND VGND VPWR VPWR sky130_fd_sc_hd__decap_3
XFILLER_70_533 VGND VGND VPWR VPWR sky130_fd_sc_hd__decap_3
XFILLER_82_382 VGND VGND VPWR VPWR sky130_fd_sc_hd__fill_2
XFILLER_82_393 VGND VGND VPWR VPWR sky130_fd_sc_hd__decap_3
XFILLER_42_268 VGND VGND VPWR VPWR sky130_fd_sc_hd__decap_3
XFILLER_10_121 VGND VGND VPWR VPWR sky130_fd_sc_hd__decap_3
XFILLER_11_688 VGND VGND VPWR VPWR sky130_fd_sc_hd__decap_3
XFILLER_6_103 VGND VGND VPWR VPWR sky130_fd_sc_hd__decap_3
XFILLER_109_576 VGND VGND VPWR VPWR sky130_fd_sc_hd__decap_3
XFILLER_12_50 VGND VGND VPWR VPWR sky130_fd_sc_hd__decap_3
XFILLER_6_136 VGND VGND VPWR VPWR sky130_fd_sc_hd__decap_3
XFILLER_6_147 VGND VGND VPWR VPWR sky130_fd_sc_hd__decap_3
Xwire568 _3469_/A VGND VGND VPWR VPWR wire568/X sky130_fd_sc_hd__clkbuf_2
XFILLER_12_83 VGND VGND VPWR VPWR sky130_fd_sc_hd__fill_1
XFILLER_88_21 VGND VGND VPWR VPWR sky130_fd_sc_hd__decap_3
XFILLER_2_353 VGND VGND VPWR VPWR sky130_fd_sc_hd__decap_3
XFILLER_2_386 VGND VGND VPWR VPWR sky130_fd_sc_hd__decap_3
XFILLER_26_9 VGND VGND VPWR VPWR sky130_fd_sc_hd__decap_3
XFILLER_65_305 VGND VGND VPWR VPWR sky130_fd_sc_hd__decap_3
XFILLER_77_132 VGND VGND VPWR VPWR sky130_fd_sc_hd__decap_3
XFILLER_78_666 VGND VGND VPWR VPWR sky130_fd_sc_hd__decap_3
XFILLER_93_614 VGND VGND VPWR VPWR sky130_fd_sc_hd__fill_2
XFILLER_65_316 VGND VGND VPWR VPWR sky130_fd_sc_hd__decap_3
XFILLER_77_198 VGND VGND VPWR VPWR sky130_fd_sc_hd__decap_3
XFILLER_92_124 VGND VGND VPWR VPWR sky130_fd_sc_hd__decap_3
XFILLER_93_647 VGND VGND VPWR VPWR sky130_fd_sc_hd__decap_3
XFILLER_18_232 VGND VGND VPWR VPWR sky130_fd_sc_hd__fill_1
XFILLER_18_276 VGND VGND VPWR VPWR sky130_fd_sc_hd__decap_3
XFILLER_33_202 VGND VGND VPWR VPWR sky130_fd_sc_hd__decap_3
XFILLER_73_382 VGND VGND VPWR VPWR sky130_fd_sc_hd__decap_3
XFILLER_73_393 VGND VGND VPWR VPWR sky130_fd_sc_hd__decap_3
XFILLER_33_246 VGND VGND VPWR VPWR sky130_fd_sc_hd__fill_1
XFILLER_33_257 VGND VGND VPWR VPWR sky130_fd_sc_hd__decap_3
XFILLER_33_279 VGND VGND VPWR VPWR sky130_fd_sc_hd__fill_1
XTAP_TAPCELL_ROW_44_775 VGND VPWR sky130_fd_sc_hd__tapvpwrvgnd_1
XTAP_TAPCELL_ROW_16_444 VGND VPWR sky130_fd_sc_hd__tapvpwrvgnd_1
XFILLER_61_599 VGND VGND VPWR VPWR sky130_fd_sc_hd__decap_3
X_3700_ _6939_/Q _3768_/A2 _3759_/A2 _6803_/Q _3699_/X VGND VGND VPWR VPWR _3700_/X
+ sky130_fd_sc_hd__a221o_2
XFILLER_41_290 VGND VGND VPWR VPWR sky130_fd_sc_hd__decap_3
X_4680_ _4680_/A _5015_/B VGND VGND VPWR VPWR _5009_/A sky130_fd_sc_hd__nor2_2
X_3631_ _3630_/A _3630_/B _5146_/B1 VGND VGND VPWR VPWR _3631_/Y sky130_fd_sc_hd__o21ai_2
X_6350_ _6540_/A VGND VGND VPWR VPWR _6350_/Y sky130_fd_sc_hd__inv_2
X_3562_ _3562_/A _3562_/B _3561_/X VGND VGND VPWR VPWR _5362_/C sky130_fd_sc_hd__or3b_2
XFILLER_6_670 VGND VGND VPWR VPWR sky130_fd_sc_hd__decap_3
XFILLER_115_535 VGND VGND VPWR VPWR sky130_fd_sc_hd__decap_3
X_6281_ _6285_/A VGND VGND VPWR VPWR _6281_/Y sky130_fd_sc_hd__inv_2
X_3493_ _7087_/Q _4351_/A2 _3407_/X _7119_/Q VGND VGND VPWR VPWR _3493_/X sky130_fd_sc_hd__a22o_2
XFILLER_115_579 VGND VGND VPWR VPWR sky130_fd_sc_hd__decap_3
Xclkbuf_leaf_5_clk clkbuf_leaf_9_clk/A VGND VGND VPWR VPWR _7234_/CLK sky130_fd_sc_hd__clkbuf_16
X_5232_ _5232_/A0 _4716_/X _5245_/S VGND VGND VPWR VPWR _7214_/D sky130_fd_sc_hd__mux2_2
XFILLER_68_121 VGND VGND VPWR VPWR sky130_fd_sc_hd__decap_3
XFILLER_69_644 VGND VGND VPWR VPWR sky130_fd_sc_hd__decap_3
X_5163_ _5163_/A _5182_/B VGND VGND VPWR VPWR _7246_/D sky130_fd_sc_hd__and2_2
XFILLER_69_688 VGND VGND VPWR VPWR sky130_fd_sc_hd__decap_3
X_4114_ _7172_/Q _4261_/B1 _5229_/C _7140_/Q _4113_/X VGND VGND VPWR VPWR _4114_/X
+ sky130_fd_sc_hd__a221o_2
XTAP_TAPCELL_ROW_110_1568 VGND VPWR sky130_fd_sc_hd__tapvpwrvgnd_1
XFILLER_110_262 VGND VGND VPWR VPWR sky130_fd_sc_hd__fill_1
XFILLER_68_187 VGND VGND VPWR VPWR sky130_fd_sc_hd__decap_3
XFILLER_83_113 VGND VGND VPWR VPWR sky130_fd_sc_hd__decap_3
XFILLER_84_625 VGND VGND VPWR VPWR sky130_fd_sc_hd__decap_3
X_5094_ _5666_/A _6986_/D _5093_/X VGND VGND VPWR VPWR _5094_/X sky130_fd_sc_hd__a21o_2
XFILLER_110_295 VGND VGND VPWR VPWR sky130_fd_sc_hd__decap_3
XFILLER_83_146 VGND VGND VPWR VPWR sky130_fd_sc_hd__decap_3
XFILLER_84_669 VGND VGND VPWR VPWR sky130_fd_sc_hd__decap_3
X_4045_ _7085_/Q _4432_/A2 _4432_/B1 _4044_/X VGND VGND VPWR VPWR _4054_/A sky130_fd_sc_hd__o211a_2
XFILLER_17_39 VGND VGND VPWR VPWR sky130_fd_sc_hd__decap_3
XFILLER_52_511 VGND VGND VPWR VPWR sky130_fd_sc_hd__decap_3
XFILLER_71_319 VGND VGND VPWR VPWR sky130_fd_sc_hd__decap_3
XFILLER_24_224 VGND VGND VPWR VPWR sky130_fd_sc_hd__decap_3
XFILLER_64_382 VGND VGND VPWR VPWR sky130_fd_sc_hd__decap_3
XTAP_TAPCELL_ROW_65_1036 VGND VPWR sky130_fd_sc_hd__tapvpwrvgnd_1
XFILLER_24_268 VGND VGND VPWR VPWR sky130_fd_sc_hd__decap_3
XFILLER_20_430 VGND VGND VPWR VPWR sky130_fd_sc_hd__decap_3
X_4878_ _4997_/A1 _6999_/D _4870_/Y _4877_/X VGND VGND VPWR VPWR _4878_/X sky130_fd_sc_hd__a211o_2
X_6617_ _6617_/A VGND VGND VPWR VPWR _6617_/Y sky130_fd_sc_hd__inv_2
X_3829_ _6908_/Q _3884_/A2 _3883_/B1 _6900_/Q VGND VGND VPWR VPWR _3829_/X sky130_fd_sc_hd__a22o_2
XFILLER_106_502 VGND VGND VPWR VPWR sky130_fd_sc_hd__decap_3
XFILLER_106_524 VGND VGND VPWR VPWR sky130_fd_sc_hd__decap_3
XFILLER_4_629 VGND VGND VPWR VPWR sky130_fd_sc_hd__decap_3
X_6548_ _6548_/A VGND VGND VPWR VPWR _6548_/Y sky130_fd_sc_hd__inv_2
XFILLER_109_6 VGND VGND VPWR VPWR sky130_fd_sc_hd__decap_3
XFILLER_3_128 VGND VGND VPWR VPWR sky130_fd_sc_hd__decap_3
X_6479_ _6642_/A VGND VGND VPWR VPWR _6479_/Y sky130_fd_sc_hd__inv_2
XTAP_TAPCELL_ROW_76_1165 VGND VPWR sky130_fd_sc_hd__tapvpwrvgnd_1
XFILLER_58_24 VGND VGND VPWR VPWR sky130_fd_sc_hd__decap_3
XFILLER_99_290 VGND VGND VPWR VPWR sky130_fd_sc_hd__decap_3
XFILLER_59_143 VGND VGND VPWR VPWR sky130_fd_sc_hd__decap_3
XFILLER_87_452 VGND VGND VPWR VPWR sky130_fd_sc_hd__decap_3
XFILLER_101_273 VGND VGND VPWR VPWR sky130_fd_sc_hd__decap_3
XFILLER_114_41 VGND VGND VPWR VPWR sky130_fd_sc_hd__decap_3
XFILLER_47_305 VGND VGND VPWR VPWR sky130_fd_sc_hd__decap_3
XFILLER_59_187 VGND VGND VPWR VPWR sky130_fd_sc_hd__decap_3
XFILLER_75_614 VGND VGND VPWR VPWR sky130_fd_sc_hd__fill_2
XFILLER_75_636 VGND VGND VPWR VPWR sky130_fd_sc_hd__decap_3
XFILLER_114_74 VGND VGND VPWR VPWR sky130_fd_sc_hd__decap_3
XFILLER_114_85 VGND VGND VPWR VPWR sky130_fd_sc_hd__decap_3
XFILLER_28_530 VGND VGND VPWR VPWR sky130_fd_sc_hd__fill_2
XFILLER_75_669 VGND VGND VPWR VPWR sky130_fd_sc_hd__decap_3
XFILLER_43_500 VGND VGND VPWR VPWR sky130_fd_sc_hd__decap_3
XFILLER_55_360 VGND VGND VPWR VPWR sky130_fd_sc_hd__decap_3
XFILLER_62_319 VGND VGND VPWR VPWR sky130_fd_sc_hd__decap_3
XFILLER_74_179 VGND VGND VPWR VPWR sky130_fd_sc_hd__decap_3
XFILLER_90_628 VGND VGND VPWR VPWR sky130_fd_sc_hd__decap_3
XFILLER_55_393 VGND VGND VPWR VPWR sky130_fd_sc_hd__fill_1
XTAP_TAPCELL_ROW_87_1294 VGND VPWR sky130_fd_sc_hd__tapvpwrvgnd_1
XFILLER_15_257 VGND VGND VPWR VPWR sky130_fd_sc_hd__decap_3
XFILLER_70_352 VGND VGND VPWR VPWR sky130_fd_sc_hd__fill_1
XFILLER_70_363 VGND VGND VPWR VPWR sky130_fd_sc_hd__fill_1
XFILLER_90_11 VGND VGND VPWR VPWR sky130_fd_sc_hd__decap_3
XFILLER_30_205 VGND VGND VPWR VPWR sky130_fd_sc_hd__decap_3
XFILLER_70_374 VGND VGND VPWR VPWR sky130_fd_sc_hd__decap_3
XFILLER_90_55 VGND VGND VPWR VPWR sky130_fd_sc_hd__decap_3
XTAP_TAPCELL_ROW_13_403 VGND VPWR sky130_fd_sc_hd__tapvpwrvgnd_1
XFILLER_11_430 VGND VGND VPWR VPWR sky130_fd_sc_hd__fill_1
XFILLER_23_290 VGND VGND VPWR VPWR sky130_fd_sc_hd__fill_2
XFILLER_90_88 VGND VGND VPWR VPWR sky130_fd_sc_hd__decap_3
XTAP_TAPCELL_ROW_41_745 VGND VPWR sky130_fd_sc_hd__tapvpwrvgnd_1
XFILLER_11_474 VGND VGND VPWR VPWR sky130_fd_sc_hd__decap_3
XFILLER_23_60 VGND VGND VPWR VPWR sky130_fd_sc_hd__decap_3
XFILLER_11_496 VGND VGND VPWR VPWR sky130_fd_sc_hd__decap_3
XFILLER_23_93 VGND VGND VPWR VPWR sky130_fd_sc_hd__decap_3
XFILLER_7_434 VGND VGND VPWR VPWR sky130_fd_sc_hd__decap_3
XFILLER_109_384 VGND VGND VPWR VPWR sky130_fd_sc_hd__decap_3
XFILLER_99_53 VGND VGND VPWR VPWR sky130_fd_sc_hd__decap_3
XFILLER_3_640 VGND VGND VPWR VPWR sky130_fd_sc_hd__decap_3
XFILLER_99_75 VGND VGND VPWR VPWR sky130_fd_sc_hd__decap_3
XFILLER_3_673 VGND VGND VPWR VPWR sky130_fd_sc_hd__decap_3
XFILLER_97_205 VGND VGND VPWR VPWR sky130_fd_sc_hd__decap_3
XFILLER_2_150 VGND VGND VPWR VPWR sky130_fd_sc_hd__decap_3
XFILLER_78_430 VGND VGND VPWR VPWR sky130_fd_sc_hd__fill_2
XFILLER_65_102 VGND VGND VPWR VPWR sky130_fd_sc_hd__decap_3
XFILLER_65_113 VGND VGND VPWR VPWR sky130_fd_sc_hd__decap_3
XFILLER_66_625 VGND VGND VPWR VPWR sky130_fd_sc_hd__decap_3
XFILLER_78_474 VGND VGND VPWR VPWR sky130_fd_sc_hd__fill_2
XFILLER_93_400 VGND VGND VPWR VPWR sky130_fd_sc_hd__decap_3
XTAP_TAPCELL_ROW_49_834 VGND VPWR sky130_fd_sc_hd__tapvpwrvgnd_1
XFILLER_66_669 VGND VGND VPWR VPWR sky130_fd_sc_hd__decap_3
XTAP_TAPCELL_ROW_49_845 VGND VPWR sky130_fd_sc_hd__tapvpwrvgnd_1
XFILLER_0_53 VGND VGND VPWR VPWR sky130_fd_sc_hd__decap_3
XFILLER_53_319 VGND VGND VPWR VPWR sky130_fd_sc_hd__decap_3
XFILLER_81_617 VGND VGND VPWR VPWR sky130_fd_sc_hd__decap_3
XFILLER_93_477 VGND VGND VPWR VPWR sky130_fd_sc_hd__decap_3
XFILLER_19_596 VGND VGND VPWR VPWR sky130_fd_sc_hd__decap_3
XFILLER_34_533 VGND VGND VPWR VPWR sky130_fd_sc_hd__fill_2
XFILLER_46_382 VGND VGND VPWR VPWR sky130_fd_sc_hd__decap_3
XFILLER_80_138 VGND VGND VPWR VPWR sky130_fd_sc_hd__fill_2
XFILLER_34_555 VGND VGND VPWR VPWR sky130_fd_sc_hd__fill_2
XFILLER_34_566 VGND VGND VPWR VPWR sky130_fd_sc_hd__decap_3
XFILLER_34_577 VGND VGND VPWR VPWR sky130_fd_sc_hd__decap_3
XFILLER_61_352 VGND VGND VPWR VPWR sky130_fd_sc_hd__decap_3
XFILLER_21_205 VGND VGND VPWR VPWR sky130_fd_sc_hd__decap_3
XFILLER_61_396 VGND VGND VPWR VPWR sky130_fd_sc_hd__decap_3
X_4801_ _4801_/A _4801_/B VGND VGND VPWR VPWR _7003_/D sky130_fd_sc_hd__nor2_2
XFILLER_21_249 VGND VGND VPWR VPWR sky130_fd_sc_hd__decap_3
XFILLER_9_51 VGND VGND VPWR VPWR sky130_fd_sc_hd__decap_3
X_4663_ _4764_/B _4040_/B _4608_/Y _4659_/X _4662_/Y VGND VGND VPWR VPWR _5665_/A
+ sky130_fd_sc_hd__o32a_2
XFILLER_9_84 VGND VGND VPWR VPWR sky130_fd_sc_hd__decap_3
X_6402_ _6532_/A VGND VGND VPWR VPWR _6402_/Y sky130_fd_sc_hd__inv_2
X_3614_ _3614_/A _3614_/B VGND VGND VPWR VPWR _3746_/B sky130_fd_sc_hd__and2_2
X_7382_ clkload9/A _7382_/D _6662_/Y VGND VGND VPWR VPWR _7382_/Q sky130_fd_sc_hd__dfrtp_2
Xhold902 _7101_/Q VGND VGND VPWR VPWR _7101_/D sky130_fd_sc_hd__dlygate4sd3_1
Xhold913 _6689_/Q VGND VGND VPWR VPWR hold913/X sky130_fd_sc_hd__dlygate4sd3_1
XFILLER_115_343 VGND VGND VPWR VPWR sky130_fd_sc_hd__decap_3
Xhold924 _5674_/X VGND VGND VPWR VPWR _6687_/D sky130_fd_sc_hd__dlygate4sd3_1
Xhold935 _7030_/Q VGND VGND VPWR VPWR _5595_/A sky130_fd_sc_hd__dlygate4sd3_1
Xhold946 _6703_/Q VGND VGND VPWR VPWR hold946/X sky130_fd_sc_hd__dlygate4sd3_1
X_6333_ _6682_/A VGND VGND VPWR VPWR _6333_/Y sky130_fd_sc_hd__inv_2
X_3545_ _3545_/A _3545_/B VGND VGND VPWR VPWR _3636_/A sky130_fd_sc_hd__nor2_2
XFILLER_103_505 VGND VGND VPWR VPWR sky130_fd_sc_hd__decap_3
XFILLER_115_376 VGND VGND VPWR VPWR sky130_fd_sc_hd__fill_2
Xhold979 _7045_/Q VGND VGND VPWR VPWR hold979/X sky130_fd_sc_hd__dlygate4sd3_1
Xhold968 _7053_/Q VGND VGND VPWR VPWR hold968/X sky130_fd_sc_hd__dlygate4sd3_1
Xhold957 _7384_/Q VGND VGND VPWR VPWR hold957/X sky130_fd_sc_hd__dlygate4sd3_1
X_6264_ _6642_/A VGND VGND VPWR VPWR _6264_/Y sky130_fd_sc_hd__inv_2
X_3476_ _7056_/Q _3577_/B _3590_/A VGND VGND VPWR VPWR _3502_/B sky130_fd_sc_hd__o21ai_2
XFILLER_103_549 VGND VGND VPWR VPWR sky130_fd_sc_hd__decap_3
XFILLER_88_249 VGND VGND VPWR VPWR sky130_fd_sc_hd__decap_3
X_5215_ _7221_/Q _5221_/B VGND VGND VPWR VPWR _7221_/D sky130_fd_sc_hd__and2_2
XFILLER_57_603 VGND VGND VPWR VPWR sky130_fd_sc_hd__decap_3
XFILLER_69_430 VGND VGND VPWR VPWR sky130_fd_sc_hd__decap_3
XFILLER_69_452 VGND VGND VPWR VPWR sky130_fd_sc_hd__decap_3
XFILLER_111_582 VGND VGND VPWR VPWR sky130_fd_sc_hd__decap_3
XFILLER_28_27 VGND VGND VPWR VPWR sky130_fd_sc_hd__fill_1
X_5146_ _5145_/A _3541_/X _5146_/B1 VGND VGND VPWR VPWR _5146_/Y sky130_fd_sc_hd__o21ai_2
XFILLER_29_349 VGND VGND VPWR VPWR sky130_fd_sc_hd__decap_3
XFILLER_57_647 VGND VGND VPWR VPWR sky130_fd_sc_hd__decap_3
X_5077_ _4832_/A _3863_/X _5658_/A VGND VGND VPWR VPWR _5077_/X sky130_fd_sc_hd__a21o_2
XFILLER_56_168 VGND VGND VPWR VPWR sky130_fd_sc_hd__decap_3
XFILLER_72_639 VGND VGND VPWR VPWR sky130_fd_sc_hd__decap_3
XFILLER_84_477 VGND VGND VPWR VPWR sky130_fd_sc_hd__decap_3
XFILLER_37_382 VGND VGND VPWR VPWR sky130_fd_sc_hd__fill_1
XFILLER_37_393 VGND VGND VPWR VPWR sky130_fd_sc_hd__decap_3
XFILLER_44_15 VGND VGND VPWR VPWR sky130_fd_sc_hd__decap_3
XFILLER_65_691 VGND VGND VPWR VPWR sky130_fd_sc_hd__fill_1
XFILLER_71_116 VGND VGND VPWR VPWR sky130_fd_sc_hd__decap_3
XFILLER_71_138 VGND VGND VPWR VPWR sky130_fd_sc_hd__decap_3
XFILLER_52_330 VGND VGND VPWR VPWR sky130_fd_sc_hd__decap_3
XFILLER_12_227 VGND VGND VPWR VPWR sky130_fd_sc_hd__decap_3
XFILLER_40_514 VGND VGND VPWR VPWR sky130_fd_sc_hd__decap_3
XFILLER_40_536 VGND VGND VPWR VPWR sky130_fd_sc_hd__decap_3
XFILLER_80_672 VGND VGND VPWR VPWR sky130_fd_sc_hd__decap_3
XFILLER_100_32 VGND VGND VPWR VPWR sky130_fd_sc_hd__decap_3
XFILLER_100_43 VGND VGND VPWR VPWR sky130_fd_sc_hd__decap_3
XFILLER_60_36 VGND VGND VPWR VPWR sky130_fd_sc_hd__decap_3
XFILLER_109_30 VGND VGND VPWR VPWR sky130_fd_sc_hd__decap_3
XFILLER_4_415 VGND VGND VPWR VPWR sky130_fd_sc_hd__decap_3
XFILLER_109_63 VGND VGND VPWR VPWR sky130_fd_sc_hd__decap_3
XFILLER_4_448 VGND VGND VPWR VPWR sky130_fd_sc_hd__decap_3
XFILLER_69_12 VGND VGND VPWR VPWR sky130_fd_sc_hd__decap_3
XFILLER_109_96 VGND VGND VPWR VPWR sky130_fd_sc_hd__decap_3
XFILLER_106_398 VGND VGND VPWR VPWR sky130_fd_sc_hd__decap_3
XFILLER_69_78 VGND VGND VPWR VPWR sky130_fd_sc_hd__decap_3
XFILLER_79_249 VGND VGND VPWR VPWR sky130_fd_sc_hd__decap_3
XFILLER_0_654 VGND VGND VPWR VPWR sky130_fd_sc_hd__decap_3
XFILLER_48_625 VGND VGND VPWR VPWR sky130_fd_sc_hd__decap_3
XFILLER_75_411 VGND VGND VPWR VPWR sky130_fd_sc_hd__decap_3
XFILLER_85_11 VGND VGND VPWR VPWR sky130_fd_sc_hd__decap_3
XFILLER_47_146 VGND VGND VPWR VPWR sky130_fd_sc_hd__decap_3
XFILLER_48_669 VGND VGND VPWR VPWR sky130_fd_sc_hd__decap_3
XFILLER_87_293 VGND VGND VPWR VPWR sky130_fd_sc_hd__fill_1
XTAP_TAPCELL_ROW_89_1323 VGND VPWR sky130_fd_sc_hd__tapvpwrvgnd_1
XFILLER_47_157 VGND VGND VPWR VPWR sky130_fd_sc_hd__decap_3
XFILLER_63_617 VGND VGND VPWR VPWR sky130_fd_sc_hd__decap_3
XTAP_TAPCELL_ROW_46_804 VGND VPWR sky130_fd_sc_hd__tapvpwrvgnd_1
XFILLER_56_680 VGND VGND VPWR VPWR sky130_fd_sc_hd__decap_3
XFILLER_62_116 VGND VGND VPWR VPWR sky130_fd_sc_hd__decap_3
XFILLER_16_544 VGND VGND VPWR VPWR sky130_fd_sc_hd__decap_3
XFILLER_71_650 VGND VGND VPWR VPWR sky130_fd_sc_hd__decap_3
XFILLER_31_514 VGND VGND VPWR VPWR sky130_fd_sc_hd__decap_3
XFILLER_70_171 VGND VGND VPWR VPWR sky130_fd_sc_hd__decap_3
XTAP_TAPCELL_ROW_26_561 VGND VPWR sky130_fd_sc_hd__tapvpwrvgnd_1
XFILLER_34_70 VGND VGND VPWR VPWR sky130_fd_sc_hd__decap_3
XFILLER_43_396 VGND VGND VPWR VPWR sky130_fd_sc_hd__fill_1
XFILLER_93_9 VGND VGND VPWR VPWR sky130_fd_sc_hd__decap_3
XFILLER_7_220 VGND VGND VPWR VPWR sky130_fd_sc_hd__decap_3
XFILLER_7_231 VGND VGND VPWR VPWR sky130_fd_sc_hd__fill_1
XFILLER_7_253 VGND VGND VPWR VPWR sky130_fd_sc_hd__decap_3
XFILLER_109_181 VGND VGND VPWR VPWR sky130_fd_sc_hd__decap_3
XFILLER_116_129 VGND VGND VPWR VPWR sky130_fd_sc_hd__decap_3
XFILLER_50_91 VGND VGND VPWR VPWR sky130_fd_sc_hd__fill_1
X_3330_ _6982_/Q VGND VGND VPWR VPWR _3330_/Y sky130_fd_sc_hd__inv_2
XFILLER_98_536 VGND VGND VPWR VPWR sky130_fd_sc_hd__decap_3
XFILLER_100_508 VGND VGND VPWR VPWR sky130_fd_sc_hd__decap_3
XFILLER_112_357 VGND VGND VPWR VPWR sky130_fd_sc_hd__decap_3
XFILLER_112_368 VGND VGND VPWR VPWR sky130_fd_sc_hd__fill_2
X_5000_ _6991_/Q _5026_/A VGND VGND VPWR VPWR _5001_/B sky130_fd_sc_hd__nor2_2
XPHY_EDGE_ROW_0_Left_117 VGND VGND VPWR VPWR sky130_fd_sc_hd__decap_3
XFILLER_22_3 VGND VGND VPWR VPWR sky130_fd_sc_hd__decap_3
XFILLER_38_102 VGND VGND VPWR VPWR sky130_fd_sc_hd__decap_3
XFILLER_66_400 VGND VGND VPWR VPWR sky130_fd_sc_hd__decap_3
XFILLER_78_271 VGND VGND VPWR VPWR sky130_fd_sc_hd__fill_2
XFILLER_85_219 VGND VGND VPWR VPWR sky130_fd_sc_hd__decap_3
Xsingle_cycle_cpu VGND VGND VPWR VPWR single_cycle_cpu/HI instruction_out[19] sky130_fd_sc_hd__conb_1
XFILLER_66_455 VGND VGND VPWR VPWR sky130_fd_sc_hd__decap_3
XFILLER_38_179 VGND VGND VPWR VPWR sky130_fd_sc_hd__decap_3
XFILLER_54_628 VGND VGND VPWR VPWR sky130_fd_sc_hd__decap_3
XFILLER_47_691 VGND VGND VPWR VPWR sky130_fd_sc_hd__fill_1
XFILLER_81_425 VGND VGND VPWR VPWR sky130_fd_sc_hd__decap_3
XFILLER_81_436 VGND VGND VPWR VPWR sky130_fd_sc_hd__fill_1
X_6951_ _6978_/CLK _6951_/D VGND VGND VPWR VPWR _6951_/Q sky130_fd_sc_hd__dfxtp_2
XFILLER_53_149 VGND VGND VPWR VPWR sky130_fd_sc_hd__decap_3
XFILLER_81_458 VGND VGND VPWR VPWR sky130_fd_sc_hd__fill_2
X_6882_ _6975_/CLK _6882_/D VGND VGND VPWR VPWR _6882_/Q sky130_fd_sc_hd__dfxtp_2
XFILLER_14_18 VGND VGND VPWR VPWR sky130_fd_sc_hd__decap_3
XFILLER_34_374 VGND VGND VPWR VPWR sky130_fd_sc_hd__decap_3
XFILLER_62_672 VGND VGND VPWR VPWR sky130_fd_sc_hd__decap_3
XFILLER_14_29 VGND VGND VPWR VPWR sky130_fd_sc_hd__decap_3
XFILLER_22_536 VGND VGND VPWR VPWR sky130_fd_sc_hd__fill_1
XFILLER_34_396 VGND VGND VPWR VPWR sky130_fd_sc_hd__fill_2
XFILLER_61_193 VGND VGND VPWR VPWR sky130_fd_sc_hd__decap_3
X_5695_ _7353_/Q hold925/X _5721_/S VGND VGND VPWR VPWR _6697_/D sky130_fd_sc_hd__mux2_2
XFILLER_108_619 VGND VGND VPWR VPWR sky130_fd_sc_hd__decap_3
XFILLER_30_17 VGND VGND VPWR VPWR sky130_fd_sc_hd__decap_3
X_4646_ _4646_/A _4646_/B VGND VGND VPWR VPWR _4646_/Y sky130_fd_sc_hd__nand2_2
XFILLER_116_641 VGND VGND VPWR VPWR sky130_fd_sc_hd__decap_3
X_7365_ _7368_/CLK _7365_/D _6645_/Y VGND VGND VPWR VPWR _7365_/Q sky130_fd_sc_hd__dfrtp_2
Xhold710 _6750_/Q VGND VGND VPWR VPWR _6750_/D sky130_fd_sc_hd__dlygate4sd3_1
Xhold721 _6886_/Q VGND VGND VPWR VPWR _6886_/D sky130_fd_sc_hd__dlygate4sd3_1
X_4577_ _4577_/A _4577_/B VGND VGND VPWR VPWR _7292_/D sky130_fd_sc_hd__and2_2
XFILLER_115_140 VGND VGND VPWR VPWR sky130_fd_sc_hd__decap_3
XFILLER_89_503 VGND VGND VPWR VPWR sky130_fd_sc_hd__fill_1
Xhold732 _6936_/Q VGND VGND VPWR VPWR _6936_/D sky130_fd_sc_hd__dlygate4sd3_1
Xhold743 _6901_/Q VGND VGND VPWR VPWR _6901_/D sky130_fd_sc_hd__dlygate4sd3_1
Xhold754 _6921_/Q VGND VGND VPWR VPWR _6921_/D sky130_fd_sc_hd__dlygate4sd3_1
X_6316_ _6640_/A VGND VGND VPWR VPWR _6316_/Y sky130_fd_sc_hd__inv_2
XFILLER_103_302 VGND VGND VPWR VPWR sky130_fd_sc_hd__decap_3
XFILLER_115_184 VGND VGND VPWR VPWR sky130_fd_sc_hd__decap_3
XFILLER_1_429 VGND VGND VPWR VPWR sky130_fd_sc_hd__decap_3
XFILLER_39_15 VGND VGND VPWR VPWR sky130_fd_sc_hd__decap_3
XFILLER_89_536 VGND VGND VPWR VPWR sky130_fd_sc_hd__decap_3
X_7296_ _7364_/CLK _7296_/D _6576_/Y VGND VGND VPWR VPWR _7296_/Q sky130_fd_sc_hd__dfrtp_2
Xhold765 _6721_/Q VGND VGND VPWR VPWR _6721_/D sky130_fd_sc_hd__dlygate4sd3_1
Xhold776 _6745_/Q VGND VGND VPWR VPWR _6745_/D sky130_fd_sc_hd__dlygate4sd3_1
Xhold787 _6836_/Q VGND VGND VPWR VPWR _6836_/D sky130_fd_sc_hd__dlygate4sd3_1
X_3528_ _3528_/A _5118_/D VGND VGND VPWR VPWR _5659_/A sky130_fd_sc_hd__or2_2
XTAP_TAPCELL_ROW_73_1124 VGND VPWR sky130_fd_sc_hd__tapvpwrvgnd_1
XFILLER_89_558 VGND VGND VPWR VPWR sky130_fd_sc_hd__fill_2
Xhold798 _6809_/Q VGND VGND VPWR VPWR _6809_/D sky130_fd_sc_hd__dlygate4sd3_1
X_3459_ _7217_/Q _3377_/X _4303_/B1 _7121_/Q VGND VGND VPWR VPWR _3459_/X sky130_fd_sc_hd__a22o_2
XFILLER_103_379 VGND VGND VPWR VPWR sky130_fd_sc_hd__decap_3
XFILLER_69_260 VGND VGND VPWR VPWR sky130_fd_sc_hd__decap_3
XFILLER_69_293 VGND VGND VPWR VPWR sky130_fd_sc_hd__decap_3
X_5129_ _5129_/A _6979_/Q VGND VGND VPWR VPWR _5130_/C sky130_fd_sc_hd__nor2_2
XFILLER_29_157 VGND VGND VPWR VPWR sky130_fd_sc_hd__fill_2
XFILLER_45_617 VGND VGND VPWR VPWR sky130_fd_sc_hd__decap_3
XFILLER_44_127 VGND VGND VPWR VPWR sky130_fd_sc_hd__fill_2
XFILLER_55_36 VGND VGND VPWR VPWR sky130_fd_sc_hd__decap_3
XFILLER_55_69 VGND VGND VPWR VPWR sky130_fd_sc_hd__decap_3
XFILLER_72_414 VGND VGND VPWR VPWR sky130_fd_sc_hd__decap_3
XFILLER_72_436 VGND VGND VPWR VPWR sky130_fd_sc_hd__fill_1
XFILLER_72_447 VGND VGND VPWR VPWR sky130_fd_sc_hd__decap_3
XFILLER_111_20 VGND VGND VPWR VPWR sky130_fd_sc_hd__decap_3
XFILLER_25_352 VGND VGND VPWR VPWR sky130_fd_sc_hd__decap_3
XFILLER_53_650 VGND VGND VPWR VPWR sky130_fd_sc_hd__decap_3
XFILLER_111_53 VGND VGND VPWR VPWR sky130_fd_sc_hd__decap_3
XFILLER_80_480 VGND VGND VPWR VPWR sky130_fd_sc_hd__decap_3
XTAP_TAPCELL_ROW_84_1264 VGND VPWR sky130_fd_sc_hd__tapvpwrvgnd_1
XFILLER_111_75 VGND VGND VPWR VPWR sky130_fd_sc_hd__decap_3
XFILLER_25_396 VGND VGND VPWR VPWR sky130_fd_sc_hd__decap_3
XFILLER_40_333 VGND VGND VPWR VPWR sky130_fd_sc_hd__decap_3
XFILLER_71_24 VGND VGND VPWR VPWR sky130_fd_sc_hd__decap_3
XTAP_TAPCELL_ROW_23_531 VGND VPWR sky130_fd_sc_hd__tapvpwrvgnd_1
XFILLER_71_57 VGND VGND VPWR VPWR sky130_fd_sc_hd__fill_2
XTAP_TAPCELL_ROW_51_862 VGND VPWR sky130_fd_sc_hd__tapvpwrvgnd_1
XFILLER_107_641 VGND VGND VPWR VPWR sky130_fd_sc_hd__decap_3
XFILLER_20_61 VGND VGND VPWR VPWR sky130_fd_sc_hd__decap_3
XFILLER_107_685 VGND VGND VPWR VPWR sky130_fd_sc_hd__decap_3
XFILLER_4_289 VGND VGND VPWR VPWR sky130_fd_sc_hd__decap_3
XTAP_TAPCELL_ROW_95_1393 VGND VPWR sky130_fd_sc_hd__tapvpwrvgnd_1
XFILLER_96_32 VGND VGND VPWR VPWR sky130_fd_sc_hd__decap_3
XFILLER_0_473 VGND VGND VPWR VPWR sky130_fd_sc_hd__decap_3
XFILLER_96_65 VGND VGND VPWR VPWR sky130_fd_sc_hd__decap_3
XFILLER_48_433 VGND VGND VPWR VPWR sky130_fd_sc_hd__fill_1
XTAP_TAPCELL_ROW_59_962 VGND VPWR sky130_fd_sc_hd__tapvpwrvgnd_1
XFILLER_35_116 VGND VGND VPWR VPWR sky130_fd_sc_hd__decap_3
XFILLER_36_639 VGND VGND VPWR VPWR sky130_fd_sc_hd__decap_3
XFILLER_63_447 VGND VGND VPWR VPWR sky130_fd_sc_hd__fill_1
XFILLER_90_200 VGND VGND VPWR VPWR sky130_fd_sc_hd__decap_3
Xplace403 _3562_/A VGND VGND VPWR VPWR _4503_/S sky130_fd_sc_hd__buf_2
Xplace414 _3380_/Y VGND VGND VPWR VPWR _4196_/A2 sky130_fd_sc_hd__buf_2
Xplace425 _4268_/A2 VGND VGND VPWR VPWR _3964_/S sky130_fd_sc_hd__buf_2
Xplace436 _4836_/S VGND VGND VPWR VPWR _5156_/S sky130_fd_sc_hd__buf_2
Xplace447 _3318_/B VGND VGND VPWR VPWR _4433_/B sky130_fd_sc_hd__buf_2
XPHY_EDGE_ROW_82_Left_199 VGND VGND VPWR VPWR sky130_fd_sc_hd__decap_3
XFILLER_16_352 VGND VGND VPWR VPWR sky130_fd_sc_hd__decap_3
XFILLER_43_160 VGND VGND VPWR VPWR sky130_fd_sc_hd__fill_1
XFILLER_45_80 VGND VGND VPWR VPWR sky130_fd_sc_hd__decap_3
XFILLER_90_277 VGND VGND VPWR VPWR sky130_fd_sc_hd__decap_3
Xplace458 _3353_/A VGND VGND VPWR VPWR _3365_/A sky130_fd_sc_hd__buf_2
XFILLER_91_6 VGND VGND VPWR VPWR sky130_fd_sc_hd__decap_3
XFILLER_31_377 VGND VGND VPWR VPWR sky130_fd_sc_hd__decap_3
XANTENNA_1 _5117_/B VGND VGND VPWR VPWR sky130_fd_sc_hd__diode_2
XFILLER_6_41 VGND VGND VPWR VPWR sky130_fd_sc_hd__decap_3
X_4431_ _7271_/Q _4437_/A2 _4428_/X _4430_/X VGND VGND VPWR VPWR _4431_/X sky130_fd_sc_hd__a211o_2
XFILLER_6_74 VGND VGND VPWR VPWR sky130_fd_sc_hd__decap_3
XFILLER_6_85 VGND VGND VPWR VPWR sky130_fd_sc_hd__decap_3
XFILLER_113_600 VGND VGND VPWR VPWR sky130_fd_sc_hd__decap_3
X_7150_ _7374_/CLK _7150_/D _6430_/Y VGND VGND VPWR VPWR _7150_/Q sky130_fd_sc_hd__dfrtp_2
X_4362_ _4362_/A _4362_/B _4362_/C VGND VGND VPWR VPWR _4362_/X sky130_fd_sc_hd__and3_2
XFILLER_98_322 VGND VGND VPWR VPWR sky130_fd_sc_hd__decap_3
XFILLER_112_121 VGND VGND VPWR VPWR sky130_fd_sc_hd__decap_3
XFILLER_113_644 VGND VGND VPWR VPWR sky130_fd_sc_hd__decap_3
X_7081_ _7234_/CLK _7081_/D _6361_/Y VGND VGND VPWR VPWR _7081_/Q sky130_fd_sc_hd__dfrtp_2
X_4293_ _4612_/A _4612_/B VGND VGND VPWR VPWR _4293_/X sky130_fd_sc_hd__and2b_2
X_3313_ _4697_/A _3353_/A _3327_/A _3342_/B VGND VGND VPWR VPWR _4467_/B sky130_fd_sc_hd__nand4b_4
XFILLER_98_355 VGND VGND VPWR VPWR sky130_fd_sc_hd__decap_3
XFILLER_112_165 VGND VGND VPWR VPWR sky130_fd_sc_hd__decap_3
XFILLER_86_539 VGND VGND VPWR VPWR sky130_fd_sc_hd__decap_3
XFILLER_98_388 VGND VGND VPWR VPWR sky130_fd_sc_hd__decap_3
XFILLER_27_617 VGND VGND VPWR VPWR sky130_fd_sc_hd__fill_2
XFILLER_39_455 VGND VGND VPWR VPWR sky130_fd_sc_hd__decap_3
XFILLER_94_572 VGND VGND VPWR VPWR sky130_fd_sc_hd__decap_3
XFILLER_26_138 VGND VGND VPWR VPWR sky130_fd_sc_hd__fill_2
XFILLER_54_447 VGND VGND VPWR VPWR sky130_fd_sc_hd__fill_1
XFILLER_81_255 VGND VGND VPWR VPWR sky130_fd_sc_hd__fill_2
X_6934_ _7406_/CLK _6934_/D VGND VGND VPWR VPWR _6934_/Q sky130_fd_sc_hd__dfxtp_2
XTAP_TAPCELL_ROW_1_259 VGND VPWR sky130_fd_sc_hd__tapvpwrvgnd_1
XFILLER_22_300 VGND VGND VPWR VPWR sky130_fd_sc_hd__decap_3
XFILLER_25_39 VGND VGND VPWR VPWR sky130_fd_sc_hd__decap_3
XFILLER_41_119 VGND VGND VPWR VPWR sky130_fd_sc_hd__decap_3
XFILLER_22_333 VGND VGND VPWR VPWR sky130_fd_sc_hd__decap_3
XFILLER_34_182 VGND VGND VPWR VPWR sky130_fd_sc_hd__fill_1
XFILLER_50_642 VGND VGND VPWR VPWR sky130_fd_sc_hd__fill_2
X_6865_ _7386_/CLK _6865_/D VGND VGND VPWR VPWR _6865_/Q sky130_fd_sc_hd__dfxtp_2
XFILLER_50_675 VGND VGND VPWR VPWR sky130_fd_sc_hd__decap_3
X_6796_ _7406_/CLK _6796_/D VGND VGND VPWR VPWR _6796_/Q sky130_fd_sc_hd__dfxtp_2
X_5678_ _7345_/Q hold913/X _5706_/S VGND VGND VPWR VPWR _5678_/X sky130_fd_sc_hd__mux2_2
X_4629_ _4629_/A _4629_/B VGND VGND VPWR VPWR _4629_/Y sky130_fd_sc_hd__nor2_2
XFILLER_104_622 VGND VGND VPWR VPWR sky130_fd_sc_hd__decap_3
X_7348_ _7352_/CLK _7348_/D _6628_/Y VGND VGND VPWR VPWR _7348_/Q sky130_fd_sc_hd__dfrtp_2
XFILLER_103_110 VGND VGND VPWR VPWR sky130_fd_sc_hd__fill_2
XFILLER_104_666 VGND VGND VPWR VPWR sky130_fd_sc_hd__decap_3
X_7279_ _7312_/CLK _7279_/D _6559_/Y VGND VGND VPWR VPWR _7279_/Q sky130_fd_sc_hd__dfrtp_2
Xhold584 _6874_/Q VGND VGND VPWR VPWR _6874_/D sky130_fd_sc_hd__dlygate4sd3_1
Xhold595 _6912_/Q VGND VGND VPWR VPWR _6912_/D sky130_fd_sc_hd__dlygate4sd3_1
XTAP_TAPCELL_ROW_9_359 VGND VPWR sky130_fd_sc_hd__tapvpwrvgnd_1
XFILLER_106_53 VGND VGND VPWR VPWR sky130_fd_sc_hd__decap_3
XFILLER_77_517 VGND VGND VPWR VPWR sky130_fd_sc_hd__decap_3
XFILLER_89_399 VGND VGND VPWR VPWR sky130_fd_sc_hd__decap_3
XFILLER_103_198 VGND VGND VPWR VPWR sky130_fd_sc_hd__decap_3
XFILLER_66_24 VGND VGND VPWR VPWR sky130_fd_sc_hd__decap_3
XFILLER_66_35 VGND VGND VPWR VPWR sky130_fd_sc_hd__fill_1
XFILLER_18_606 VGND VGND VPWR VPWR sky130_fd_sc_hd__decap_3
XFILLER_57_263 VGND VGND VPWR VPWR sky130_fd_sc_hd__decap_3
XFILLER_66_57 VGND VGND VPWR VPWR sky130_fd_sc_hd__decap_3
XFILLER_45_414 VGND VGND VPWR VPWR sky130_fd_sc_hd__decap_3
XFILLER_57_296 VGND VGND VPWR VPWR sky130_fd_sc_hd__decap_3
XTAP_TAPCELL_ROW_56_921 VGND VPWR sky130_fd_sc_hd__tapvpwrvgnd_1
XFILLER_45_447 VGND VGND VPWR VPWR sky130_fd_sc_hd__fill_1
XFILLER_82_12 VGND VGND VPWR VPWR sky130_fd_sc_hd__decap_3
XFILLER_25_160 VGND VGND VPWR VPWR sky130_fd_sc_hd__decap_3
XFILLER_32_119 VGND VGND VPWR VPWR sky130_fd_sc_hd__decap_3
XFILLER_82_56 VGND VGND VPWR VPWR sky130_fd_sc_hd__decap_3
XFILLER_41_642 VGND VGND VPWR VPWR sky130_fd_sc_hd__decap_3
XFILLER_53_480 VGND VGND VPWR VPWR sky130_fd_sc_hd__decap_3
XFILLER_15_72 VGND VGND VPWR VPWR sky130_fd_sc_hd__fill_1
XFILLER_40_141 VGND VGND VPWR VPWR sky130_fd_sc_hd__fill_2
XFILLER_41_653 VGND VGND VPWR VPWR sky130_fd_sc_hd__fill_1
XFILLER_15_94 VGND VGND VPWR VPWR sky130_fd_sc_hd__decap_3
XFILLER_9_337 VGND VGND VPWR VPWR sky130_fd_sc_hd__decap_3
XTAP_TAPCELL_ROW_97_1411 VGND VPWR sky130_fd_sc_hd__tapvpwrvgnd_1
XFILLER_31_60 VGND VGND VPWR VPWR sky130_fd_sc_hd__decap_3
XFILLER_56_9 VGND VGND VPWR VPWR sky130_fd_sc_hd__decap_3
XFILLER_99_108 VGND VGND VPWR VPWR sky130_fd_sc_hd__decap_3
XFILLER_114_419 VGND VGND VPWR VPWR sky130_fd_sc_hd__fill_1
XFILLER_5_576 VGND VGND VPWR VPWR sky130_fd_sc_hd__decap_3
XFILLER_99_119 VGND VGND VPWR VPWR sky130_fd_sc_hd__decap_3
XFILLER_110_625 VGND VGND VPWR VPWR sky130_fd_sc_hd__decap_3
XFILLER_0_270 VGND VGND VPWR VPWR sky130_fd_sc_hd__decap_3
XFILLER_0_292 VGND VGND VPWR VPWR sky130_fd_sc_hd__decap_3
XFILLER_110_669 VGND VGND VPWR VPWR sky130_fd_sc_hd__decap_3
XFILLER_48_285 VGND VGND VPWR VPWR sky130_fd_sc_hd__decap_3
XFILLER_63_211 VGND VGND VPWR VPWR sky130_fd_sc_hd__fill_1
XFILLER_91_520 VGND VGND VPWR VPWR sky130_fd_sc_hd__decap_3
XPHY_EDGE_ROW_90_Left_207 VGND VGND VPWR VPWR sky130_fd_sc_hd__decap_3
XFILLER_63_255 VGND VGND VPWR VPWR sky130_fd_sc_hd__decap_3
XFILLER_91_564 VGND VGND VPWR VPWR sky130_fd_sc_hd__fill_1
XFILLER_23_108 VGND VGND VPWR VPWR sky130_fd_sc_hd__decap_3
XFILLER_23_119 VGND VGND VPWR VPWR sky130_fd_sc_hd__decap_3
XFILLER_16_182 VGND VGND VPWR VPWR sky130_fd_sc_hd__decap_3
XFILLER_16_193 VGND VGND VPWR VPWR sky130_fd_sc_hd__decap_3
XFILLER_63_299 VGND VGND VPWR VPWR sky130_fd_sc_hd__decap_3
Xplace288 _3656_/Y VGND VGND VPWR VPWR _3887_/A2 sky130_fd_sc_hd__buf_2
Xplace277 _3892_/A2 VGND VGND VPWR VPWR _3879_/A2 sky130_fd_sc_hd__buf_2
Xplace266 _3665_/X VGND VGND VPWR VPWR _3917_/B1 sky130_fd_sc_hd__buf_2
X_3931_ _7374_/Q _4474_/A0 _3935_/S VGND VGND VPWR VPWR _3931_/X sky130_fd_sc_hd__mux2_2
XTAP_TAPCELL_ROW_34_659 VGND VPWR sky130_fd_sc_hd__tapvpwrvgnd_1
XFILLER_31_141 VGND VGND VPWR VPWR sky130_fd_sc_hd__decap_3
Xplace299 _3634_/Y VGND VGND VPWR VPWR _3991_/B sky130_fd_sc_hd__buf_2
X_6650_ _6683_/A VGND VGND VPWR VPWR _6650_/Y sky130_fd_sc_hd__inv_2
X_3862_ _6923_/Q _3902_/A2 _3862_/B1 _6787_/Q VGND VGND VPWR VPWR _3862_/X sky130_fd_sc_hd__a22o_2
X_6581_ _6642_/A VGND VGND VPWR VPWR _6581_/Y sky130_fd_sc_hd__inv_2
XFILLER_31_196 VGND VGND VPWR VPWR sky130_fd_sc_hd__decap_3
X_3793_ _6756_/Q _3884_/B1 _3888_/B1 _6768_/Q VGND VGND VPWR VPWR _3793_/X sky130_fd_sc_hd__a22o_2
XFILLER_8_381 VGND VGND VPWR VPWR sky130_fd_sc_hd__fill_1
XFILLER_105_408 VGND VGND VPWR VPWR sky130_fd_sc_hd__decap_3
X_7202_ _7266_/CLK _7202_/D _6482_/Y VGND VGND VPWR VPWR _7202_/Q sky130_fd_sc_hd__dfrtp_2
X_5394_ _5394_/A0 _4964_/X _5429_/S VGND VGND VPWR VPWR _7136_/D sky130_fd_sc_hd__mux2_2
X_4414_ _7240_/Q _4433_/B _3958_/S _7208_/Q VGND VGND VPWR VPWR _4414_/X sky130_fd_sc_hd__a22o_2
XFILLER_99_620 VGND VGND VPWR VPWR sky130_fd_sc_hd__decap_3
XFILLER_113_441 VGND VGND VPWR VPWR sky130_fd_sc_hd__fill_1
X_7133_ _7294_/CLK _7133_/D _6413_/Y VGND VGND VPWR VPWR _7133_/Q sky130_fd_sc_hd__dfrtp_2
X_4345_ _4343_/X _4345_/B VGND VGND VPWR VPWR _5101_/B sky130_fd_sc_hd__nand2b_2
XFILLER_99_653 VGND VGND VPWR VPWR sky130_fd_sc_hd__decap_3
XFILLER_101_603 VGND VGND VPWR VPWR sky130_fd_sc_hd__decap_3
XTAP_TAPCELL_ROW_6_329 VGND VPWR sky130_fd_sc_hd__tapvpwrvgnd_1
XTAP_TAPCELL_ROW_6_318 VGND VPWR sky130_fd_sc_hd__tapvpwrvgnd_1
XFILLER_100_113 VGND VGND VPWR VPWR sky130_fd_sc_hd__decap_3
XFILLER_101_647 VGND VGND VPWR VPWR sky130_fd_sc_hd__decap_3
XFILLER_113_485 VGND VGND VPWR VPWR sky130_fd_sc_hd__fill_1
X_7064_ clkload7/A _7064_/D _6344_/Y VGND VGND VPWR VPWR _7064_/Q sky130_fd_sc_hd__dfrtp_2
XFILLER_39_241 VGND VGND VPWR VPWR sky130_fd_sc_hd__decap_3
XFILLER_86_358 VGND VGND VPWR VPWR sky130_fd_sc_hd__fill_1
XFILLER_54_200 VGND VGND VPWR VPWR sky130_fd_sc_hd__decap_3
XFILLER_67_572 VGND VGND VPWR VPWR sky130_fd_sc_hd__decap_3
XFILLER_27_436 VGND VGND VPWR VPWR sky130_fd_sc_hd__decap_3
XFILLER_36_38 VGND VGND VPWR VPWR sky130_fd_sc_hd__fill_1
XFILLER_39_296 VGND VGND VPWR VPWR sky130_fd_sc_hd__decap_3
XFILLER_54_233 VGND VGND VPWR VPWR sky130_fd_sc_hd__decap_3
XFILLER_82_531 VGND VGND VPWR VPWR sky130_fd_sc_hd__fill_1
XTAP_TAPCELL_ROW_68_1067 VGND VPWR sky130_fd_sc_hd__tapvpwrvgnd_1
XFILLER_54_299 VGND VGND VPWR VPWR sky130_fd_sc_hd__decap_3
X_6917_ clkload2/A _6917_/D VGND VGND VPWR VPWR _6917_/Q sky130_fd_sc_hd__dfxtp_2
XTAP_TAPCELL_ROW_81_1223 VGND VPWR sky130_fd_sc_hd__tapvpwrvgnd_1
XFILLER_22_141 VGND VGND VPWR VPWR sky130_fd_sc_hd__decap_3
XFILLER_52_26 VGND VGND VPWR VPWR sky130_fd_sc_hd__fill_2
X_6848_ _6978_/CLK _6848_/D VGND VGND VPWR VPWR _6848_/Q sky130_fd_sc_hd__dfxtp_2
XFILLER_10_347 VGND VGND VPWR VPWR sky130_fd_sc_hd__decap_3
XFILLER_6_307 VGND VGND VPWR VPWR sky130_fd_sc_hd__fill_1
X_6779_ _7383_/CLK _6779_/D VGND VGND VPWR VPWR _6779_/Q sky130_fd_sc_hd__dfxtp_2
XFILLER_108_224 VGND VGND VPWR VPWR sky130_fd_sc_hd__decap_3
XFILLER_6_329 VGND VGND VPWR VPWR sky130_fd_sc_hd__fill_1
XTAP_TAPCELL_ROW_79_1196 VGND VPWR sky130_fd_sc_hd__tapvpwrvgnd_1
XFILLER_77_12 VGND VGND VPWR VPWR sky130_fd_sc_hd__decap_3
XTAP_TAPCELL_ROW_92_1352 VGND VPWR sky130_fd_sc_hd__tapvpwrvgnd_1
XFILLER_104_474 VGND VGND VPWR VPWR sky130_fd_sc_hd__fill_2
XFILLER_89_152 VGND VGND VPWR VPWR sky130_fd_sc_hd__decap_3
XFILLER_104_496 VGND VGND VPWR VPWR sky130_fd_sc_hd__fill_2
XFILLER_58_572 VGND VGND VPWR VPWR sky130_fd_sc_hd__decap_3
XFILLER_73_542 VGND VGND VPWR VPWR sky130_fd_sc_hd__decap_3
XFILLER_93_66 VGND VGND VPWR VPWR sky130_fd_sc_hd__fill_2
Xhold1070 _7394_/Q VGND VGND VPWR VPWR _3766_/A1 sky130_fd_sc_hd__dlygate4sd3_1
Xhold1081 _7195_/Q VGND VGND VPWR VPWR _5270_/A0 sky130_fd_sc_hd__dlygate4sd3_1
Xhold1092 _7332_/Q VGND VGND VPWR VPWR _4495_/A0 sky130_fd_sc_hd__dlygate4sd3_1
XFILLER_26_60 VGND VGND VPWR VPWR sky130_fd_sc_hd__decap_3
XFILLER_73_575 VGND VGND VPWR VPWR sky130_fd_sc_hd__decap_3
XFILLER_26_480 VGND VGND VPWR VPWR sky130_fd_sc_hd__fill_1
XFILLER_60_236 VGND VGND VPWR VPWR sky130_fd_sc_hd__decap_3
XTAP_TAPCELL_ROW_31_629 VGND VPWR sky130_fd_sc_hd__tapvpwrvgnd_1
XTAP_TAPCELL_ROW_31_618 VGND VPWR sky130_fd_sc_hd__tapvpwrvgnd_1
XFILLER_13_196 VGND VGND VPWR VPWR sky130_fd_sc_hd__decap_3
XTAP_TAPCELL_ROW_11_386 VGND VPWR sky130_fd_sc_hd__tapvpwrvgnd_1
XFILLER_114_227 VGND VGND VPWR VPWR sky130_fd_sc_hd__decap_3
XFILLER_54_6 VGND VGND VPWR VPWR sky130_fd_sc_hd__decap_3
XFILLER_107_290 VGND VGND VPWR VPWR sky130_fd_sc_hd__decap_3
XFILLER_5_384 VGND VGND VPWR VPWR sky130_fd_sc_hd__decap_3
X_4130_ _7235_/Q _4349_/B1 _4261_/B1 _7171_/Q _4129_/X VGND VGND VPWR VPWR _4130_/X
+ sky130_fd_sc_hd__a221o_2
XFILLER_3_42 VGND VGND VPWR VPWR sky130_fd_sc_hd__decap_3
XFILLER_95_122 VGND VGND VPWR VPWR sky130_fd_sc_hd__decap_3
XFILLER_96_623 VGND VGND VPWR VPWR sky130_fd_sc_hd__decap_3
XFILLER_96_645 VGND VGND VPWR VPWR sky130_fd_sc_hd__decap_3
XFILLER_110_466 VGND VGND VPWR VPWR sky130_fd_sc_hd__fill_1
XFILLER_3_75 VGND VGND VPWR VPWR sky130_fd_sc_hd__decap_3
XFILLER_49_561 VGND VGND VPWR VPWR sky130_fd_sc_hd__fill_2
XFILLER_68_358 VGND VGND VPWR VPWR sky130_fd_sc_hd__decap_3
XFILLER_95_166 VGND VGND VPWR VPWR sky130_fd_sc_hd__fill_2
XFILLER_96_678 VGND VGND VPWR VPWR sky130_fd_sc_hd__decap_3
X_4061_ _7244_/Q _4433_/B _4436_/B1 _7180_/Q VGND VGND VPWR VPWR _4061_/X sky130_fd_sc_hd__a22o_2
XFILLER_110_477 VGND VGND VPWR VPWR sky130_fd_sc_hd__fill_1
XFILLER_36_200 VGND VGND VPWR VPWR sky130_fd_sc_hd__decap_3
XFILLER_49_572 VGND VGND VPWR VPWR sky130_fd_sc_hd__decap_3
XFILLER_49_594 VGND VGND VPWR VPWR sky130_fd_sc_hd__decap_3
XFILLER_64_520 VGND VGND VPWR VPWR sky130_fd_sc_hd__fill_2
XFILLER_83_317 VGND VGND VPWR VPWR sky130_fd_sc_hd__decap_3
XTAP_TAPCELL_ROW_39_718 VGND VPWR sky130_fd_sc_hd__tapvpwrvgnd_1
XFILLER_36_233 VGND VGND VPWR VPWR sky130_fd_sc_hd__decap_3
XFILLER_51_203 VGND VGND VPWR VPWR sky130_fd_sc_hd__decap_3
XFILLER_51_225 VGND VGND VPWR VPWR sky130_fd_sc_hd__decap_3
X_4963_ _4963_/A _4963_/B VGND VGND VPWR VPWR _6994_/D sky130_fd_sc_hd__nor2_2
XTAP_TAPCELL_ROW_19_475 VGND VPWR sky130_fd_sc_hd__tapvpwrvgnd_1
XFILLER_32_450 VGND VGND VPWR VPWR sky130_fd_sc_hd__decap_3
X_6702_ _7392_/CLK _6702_/D VGND VGND VPWR VPWR _6702_/Q sky130_fd_sc_hd__dfxtp_2
X_3914_ _5660_/A _3911_/X _3913_/X _3714_/X VGND VGND VPWR VPWR _3914_/X sky130_fd_sc_hd__a22o_2
X_6633_ _6640_/A VGND VGND VPWR VPWR _6633_/Y sky130_fd_sc_hd__inv_2
X_4894_ _4908_/A _4908_/B VGND VGND VPWR VPWR _4909_/B sky130_fd_sc_hd__and2_2
XFILLER_20_656 VGND VGND VPWR VPWR sky130_fd_sc_hd__fill_2
XFILLER_22_18 VGND VGND VPWR VPWR sky130_fd_sc_hd__decap_3
X_3845_ _3845_/A _3845_/B VGND VGND VPWR VPWR _3845_/X sky130_fd_sc_hd__or2_2
X_6564_ _6599_/A VGND VGND VPWR VPWR _6564_/Y sky130_fd_sc_hd__inv_2
X_3776_ _6727_/Q _3906_/A2 _3907_/A2 _6977_/Q VGND VGND VPWR VPWR _3776_/X sky130_fd_sc_hd__a22o_2
X_6495_ _6608_/A VGND VGND VPWR VPWR _6495_/Y sky130_fd_sc_hd__inv_2
XTAP_TAPCELL_ROW_115_1628 VGND VPWR sky130_fd_sc_hd__tapvpwrvgnd_1
XFILLER_105_249 VGND VGND VPWR VPWR sky130_fd_sc_hd__decap_3
XFILLER_59_303 VGND VGND VPWR VPWR sky130_fd_sc_hd__decap_3
XFILLER_87_612 VGND VGND VPWR VPWR sky130_fd_sc_hd__decap_3
Xoutput486 _5655_/A VGND VGND VPWR VPWR alu_result_out[30] sky130_fd_sc_hd__clkdlybuf4s25_1
Xoutput475 place75/X VGND VGND VPWR VPWR alu_result_out[20] sky130_fd_sc_hd__clkdlybuf4s25_1
Xoutput464 _5658_/A VGND VGND VPWR VPWR alu_result_out[10] sky130_fd_sc_hd__clkdlybuf4s25_1
X_5377_ _5377_/A0 _4822_/X _5396_/S VGND VGND VPWR VPWR _7144_/D sky130_fd_sc_hd__mux2_2
XFILLER_86_100 VGND VGND VPWR VPWR sky130_fd_sc_hd__decap_3
XFILLER_86_122 VGND VGND VPWR VPWR sky130_fd_sc_hd__decap_3
XFILLER_87_623 VGND VGND VPWR VPWR sky130_fd_sc_hd__decap_3
X_7116_ _7310_/CLK _7116_/D _6396_/Y VGND VGND VPWR VPWR _7116_/Q sky130_fd_sc_hd__dfrtp_2
Xoutput497 _5645_/X VGND VGND VPWR VPWR instruction_out[12] sky130_fd_sc_hd__clkdlybuf4s25_1
X_4328_ _4362_/A _4362_/B _4362_/C VGND VGND VPWR VPWR _5057_/B sky130_fd_sc_hd__a21boi_2
XFILLER_99_483 VGND VGND VPWR VPWR sky130_fd_sc_hd__decap_3
XFILLER_101_444 VGND VGND VPWR VPWR sky130_fd_sc_hd__decap_3
XFILLER_101_466 VGND VGND VPWR VPWR sky130_fd_sc_hd__fill_1
XFILLER_47_15 VGND VGND VPWR VPWR sky130_fd_sc_hd__decap_3
XFILLER_87_656 VGND VGND VPWR VPWR sky130_fd_sc_hd__decap_3
X_7047_ _7398_/CLK _7047_/D _6327_/Y VGND VGND VPWR VPWR _7047_/Q sky130_fd_sc_hd__dfrtp_2
XFILLER_101_488 VGND VGND VPWR VPWR sky130_fd_sc_hd__decap_3
XFILLER_74_339 VGND VGND VPWR VPWR sky130_fd_sc_hd__decap_3
XFILLER_86_166 VGND VGND VPWR VPWR sky130_fd_sc_hd__decap_3
XFILLER_103_21 VGND VGND VPWR VPWR sky130_fd_sc_hd__decap_3
XFILLER_27_255 VGND VGND VPWR VPWR sky130_fd_sc_hd__fill_1
XFILLER_27_266 VGND VGND VPWR VPWR sky130_fd_sc_hd__decap_3
XFILLER_42_203 VGND VGND VPWR VPWR sky130_fd_sc_hd__decap_3
XFILLER_63_14 VGND VGND VPWR VPWR sky130_fd_sc_hd__fill_1
XFILLER_103_98 VGND VGND VPWR VPWR sky130_fd_sc_hd__decap_3
XFILLER_27_299 VGND VGND VPWR VPWR sky130_fd_sc_hd__decap_3
XFILLER_42_225 VGND VGND VPWR VPWR sky130_fd_sc_hd__fill_1
XFILLER_55_597 VGND VGND VPWR VPWR sky130_fd_sc_hd__decap_3
XFILLER_63_25 VGND VGND VPWR VPWR sky130_fd_sc_hd__decap_3
XFILLER_63_47 VGND VGND VPWR VPWR sky130_fd_sc_hd__decap_3
XFILLER_30_409 VGND VGND VPWR VPWR sky130_fd_sc_hd__decap_3
XFILLER_10_100 VGND VGND VPWR VPWR sky130_fd_sc_hd__decap_3
XFILLER_23_483 VGND VGND VPWR VPWR sky130_fd_sc_hd__decap_3
XFILLER_70_589 VGND VGND VPWR VPWR sky130_fd_sc_hd__decap_3
XFILLER_10_133 VGND VGND VPWR VPWR sky130_fd_sc_hd__decap_3
XFILLER_11_634 VGND VGND VPWR VPWR sky130_fd_sc_hd__fill_2
XFILLER_11_645 VGND VGND VPWR VPWR sky130_fd_sc_hd__decap_3
XFILLER_11_667 VGND VGND VPWR VPWR sky130_fd_sc_hd__decap_3
XFILLER_50_280 VGND VGND VPWR VPWR sky130_fd_sc_hd__decap_3
XFILLER_109_533 VGND VGND VPWR VPWR sky130_fd_sc_hd__decap_3
XFILLER_6_115 VGND VGND VPWR VPWR sky130_fd_sc_hd__decap_3
XFILLER_7_627 VGND VGND VPWR VPWR sky130_fd_sc_hd__decap_3
XFILLER_12_62 VGND VGND VPWR VPWR sky130_fd_sc_hd__decap_3
XFILLER_109_588 VGND VGND VPWR VPWR sky130_fd_sc_hd__decap_3
XFILLER_2_321 VGND VGND VPWR VPWR sky130_fd_sc_hd__decap_3
XFILLER_111_208 VGND VGND VPWR VPWR sky130_fd_sc_hd__decap_3
XFILLER_2_365 VGND VGND VPWR VPWR sky130_fd_sc_hd__decap_3
XFILLER_78_601 VGND VGND VPWR VPWR sky130_fd_sc_hd__decap_3
XFILLER_88_66 VGND VGND VPWR VPWR sky130_fd_sc_hd__decap_3
XFILLER_88_88 VGND VGND VPWR VPWR sky130_fd_sc_hd__fill_2
XFILLER_2_398 VGND VGND VPWR VPWR sky130_fd_sc_hd__decap_3
XFILLER_77_122 VGND VGND VPWR VPWR sky130_fd_sc_hd__fill_1
XFILLER_78_634 VGND VGND VPWR VPWR sky130_fd_sc_hd__decap_3
XFILLER_78_645 VGND VGND VPWR VPWR sky130_fd_sc_hd__decap_3
XFILLER_104_293 VGND VGND VPWR VPWR sky130_fd_sc_hd__decap_3
XFILLER_77_144 VGND VGND VPWR VPWR sky130_fd_sc_hd__decap_3
XFILLER_78_678 VGND VGND VPWR VPWR sky130_fd_sc_hd__decap_3
XFILLER_65_328 VGND VGND VPWR VPWR sky130_fd_sc_hd__decap_3
XFILLER_92_103 VGND VGND VPWR VPWR sky130_fd_sc_hd__decap_3
XFILLER_93_626 VGND VGND VPWR VPWR sky130_fd_sc_hd__decap_3
XFILLER_18_211 VGND VGND VPWR VPWR sky130_fd_sc_hd__decap_3
XFILLER_46_531 VGND VGND VPWR VPWR sky130_fd_sc_hd__fill_1
XFILLER_58_380 VGND VGND VPWR VPWR sky130_fd_sc_hd__fill_1
XFILLER_92_136 VGND VGND VPWR VPWR sky130_fd_sc_hd__decap_3
XFILLER_93_659 VGND VGND VPWR VPWR sky130_fd_sc_hd__decap_3
XFILLER_46_564 VGND VGND VPWR VPWR sky130_fd_sc_hd__decap_3
XFILLER_33_214 VGND VGND VPWR VPWR sky130_fd_sc_hd__decap_3
XFILLER_33_225 VGND VGND VPWR VPWR sky130_fd_sc_hd__decap_3
XFILLER_61_556 VGND VGND VPWR VPWR sky130_fd_sc_hd__decap_3
XFILLER_61_567 VGND VGND VPWR VPWR sky130_fd_sc_hd__decap_3
XFILLER_61_578 VGND VGND VPWR VPWR sky130_fd_sc_hd__decap_3
XTAP_TAPCELL_ROW_16_445 VGND VPWR sky130_fd_sc_hd__tapvpwrvgnd_1
XFILLER_14_472 VGND VGND VPWR VPWR sky130_fd_sc_hd__decap_3
XTAP_TAPCELL_ROW_44_776 VGND VPWR sky130_fd_sc_hd__tapvpwrvgnd_1
X_3630_ _3630_/A _3630_/B VGND VGND VPWR VPWR _3636_/B sky130_fd_sc_hd__and2_2
X_3561_ _3561_/A _6983_/Q _5668_/A VGND VGND VPWR VPWR _3561_/X sky130_fd_sc_hd__or3_2
XFILLER_115_503 VGND VGND VPWR VPWR sky130_fd_sc_hd__fill_1
XFILLER_115_514 VGND VGND VPWR VPWR sky130_fd_sc_hd__decap_3
X_5300_ _5300_/A0 _4752_/X _5315_/S VGND VGND VPWR VPWR _7180_/D sky130_fd_sc_hd__mux2_2
XFILLER_115_547 VGND VGND VPWR VPWR sky130_fd_sc_hd__decap_3
XFILLER_6_682 VGND VGND VPWR VPWR sky130_fd_sc_hd__decap_3
X_6280_ _6280_/A VGND VGND VPWR VPWR _6280_/Y sky130_fd_sc_hd__inv_2
X_3492_ _7055_/Q _4305_/B _3487_/X _3491_/X VGND VGND VPWR VPWR _4460_/B sky130_fd_sc_hd__o22a_2
XFILLER_5_192 VGND VGND VPWR VPWR sky130_fd_sc_hd__decap_3
XFILLER_69_612 VGND VGND VPWR VPWR sky130_fd_sc_hd__fill_1
XFILLER_68_100 VGND VGND VPWR VPWR sky130_fd_sc_hd__decap_3
XFILLER_69_623 VGND VGND VPWR VPWR sky130_fd_sc_hd__decap_3
XFILLER_68_133 VGND VGND VPWR VPWR sky130_fd_sc_hd__decap_3
XFILLER_68_155 VGND VGND VPWR VPWR sky130_fd_sc_hd__decap_3
XFILLER_69_656 VGND VGND VPWR VPWR sky130_fd_sc_hd__decap_3
XFILLER_84_604 VGND VGND VPWR VPWR sky130_fd_sc_hd__decap_3
X_5093_ _5581_/S _3867_/X _5658_/C _5092_/X _3346_/A VGND VGND VPWR VPWR _5093_/X
+ sky130_fd_sc_hd__o32a_2
X_4113_ _7364_/Q _4196_/A2 _4112_/X _4429_/C1 VGND VGND VPWR VPWR _4113_/X sky130_fd_sc_hd__a211o_2
XTAP_TAPCELL_ROW_110_1569 VGND VPWR sky130_fd_sc_hd__tapvpwrvgnd_1
XFILLER_110_274 VGND VGND VPWR VPWR sky130_fd_sc_hd__decap_3
XFILLER_84_637 VGND VGND VPWR VPWR sky130_fd_sc_hd__decap_3
XFILLER_17_18 VGND VGND VPWR VPWR sky130_fd_sc_hd__decap_3
XFILLER_83_125 VGND VGND VPWR VPWR sky130_fd_sc_hd__decap_3
XFILLER_84_648 VGND VGND VPWR VPWR sky130_fd_sc_hd__decap_3
X_4044_ _7277_/Q _4437_/A2 _4041_/X _4043_/X VGND VGND VPWR VPWR _4044_/X sky130_fd_sc_hd__a211o_2
XFILLER_92_681 VGND VGND VPWR VPWR sky130_fd_sc_hd__decap_3
XTAP_TAPCELL_ROW_65_1037 VGND VPWR sky130_fd_sc_hd__tapvpwrvgnd_1
XTAP_TAPCELL_ROW_65_1026 VGND VPWR sky130_fd_sc_hd__tapvpwrvgnd_1
XFILLER_52_589 VGND VGND VPWR VPWR sky130_fd_sc_hd__decap_3
X_4946_ _4946_/A0 _4945_/X _4946_/S VGND VGND VPWR VPWR _7265_/D sky130_fd_sc_hd__mux2_2
XFILLER_32_280 VGND VGND VPWR VPWR sky130_fd_sc_hd__decap_3
X_4877_ _4799_/A _5663_/C _3753_/X _3346_/A VGND VGND VPWR VPWR _4877_/X sky130_fd_sc_hd__o211a_2
XFILLER_20_475 VGND VGND VPWR VPWR sky130_fd_sc_hd__fill_1
X_6616_ _6616_/A VGND VGND VPWR VPWR _6616_/Y sky130_fd_sc_hd__inv_2
X_3828_ _6926_/Q _3902_/A2 _3862_/B1 _6790_/Q _3827_/X VGND VGND VPWR VPWR _3828_/X
+ sky130_fd_sc_hd__a221o_2
X_6547_ _6547_/A VGND VGND VPWR VPWR _6547_/Y sky130_fd_sc_hd__inv_2
X_3759_ _6797_/Q _3759_/A2 _3767_/B1 _6885_/Q VGND VGND VPWR VPWR _3759_/X sky130_fd_sc_hd__a22o_2
XFILLER_106_536 VGND VGND VPWR VPWR sky130_fd_sc_hd__decap_3
X_6478_ _6644_/A VGND VGND VPWR VPWR _6478_/Y sky130_fd_sc_hd__inv_2
XTAP_TAPCELL_ROW_76_1166 VGND VPWR sky130_fd_sc_hd__tapvpwrvgnd_1
X_5429_ _7119_/Q _4470_/X _5429_/S VGND VGND VPWR VPWR _7119_/D sky130_fd_sc_hd__mux2_2
XFILLER_59_111 VGND VGND VPWR VPWR sky130_fd_sc_hd__fill_1
XFILLER_87_420 VGND VGND VPWR VPWR sky130_fd_sc_hd__decap_3
XFILLER_58_69 VGND VGND VPWR VPWR sky130_fd_sc_hd__decap_3
XFILLER_59_133 VGND VGND VPWR VPWR sky130_fd_sc_hd__decap_3
XFILLER_87_464 VGND VGND VPWR VPWR sky130_fd_sc_hd__decap_3
XFILLER_101_252 VGND VGND VPWR VPWR sky130_fd_sc_hd__decap_3
XFILLER_47_317 VGND VGND VPWR VPWR sky130_fd_sc_hd__decap_3
XFILLER_59_166 VGND VGND VPWR VPWR sky130_fd_sc_hd__fill_2
XFILLER_101_296 VGND VGND VPWR VPWR sky130_fd_sc_hd__decap_3
XFILLER_114_53 VGND VGND VPWR VPWR sky130_fd_sc_hd__decap_3
XFILLER_75_648 VGND VGND VPWR VPWR sky130_fd_sc_hd__decap_3
XFILLER_114_97 VGND VGND VPWR VPWR sky130_fd_sc_hd__decap_3
XFILLER_62_309 VGND VGND VPWR VPWR sky130_fd_sc_hd__fill_2
XFILLER_74_35 VGND VGND VPWR VPWR sky130_fd_sc_hd__decap_3
XFILLER_74_57 VGND VGND VPWR VPWR sky130_fd_sc_hd__decap_3
XFILLER_15_225 VGND VGND VPWR VPWR sky130_fd_sc_hd__decap_3
XFILLER_28_586 VGND VGND VPWR VPWR sky130_fd_sc_hd__fill_2
XFILLER_43_512 VGND VGND VPWR VPWR sky130_fd_sc_hd__decap_3
XFILLER_70_320 VGND VGND VPWR VPWR sky130_fd_sc_hd__decap_3
XTAP_TAPCELL_ROW_87_1295 VGND VPWR sky130_fd_sc_hd__tapvpwrvgnd_1
XFILLER_15_269 VGND VGND VPWR VPWR sky130_fd_sc_hd__decap_3
XFILLER_43_556 VGND VGND VPWR VPWR sky130_fd_sc_hd__decap_3
XFILLER_43_578 VGND VGND VPWR VPWR sky130_fd_sc_hd__decap_3
XFILLER_70_386 VGND VGND VPWR VPWR sky130_fd_sc_hd__decap_3
XFILLER_90_23 VGND VGND VPWR VPWR sky130_fd_sc_hd__decap_3
XTAP_TAPCELL_ROW_13_404 VGND VPWR sky130_fd_sc_hd__tapvpwrvgnd_1
XFILLER_30_239 VGND VGND VPWR VPWR sky130_fd_sc_hd__decap_3
XFILLER_90_67 VGND VGND VPWR VPWR sky130_fd_sc_hd__decap_3
XTAP_TAPCELL_ROW_41_746 VGND VPWR sky130_fd_sc_hd__tapvpwrvgnd_1
XFILLER_23_72 VGND VGND VPWR VPWR sky130_fd_sc_hd__decap_3
XFILLER_7_402 VGND VGND VPWR VPWR sky130_fd_sc_hd__fill_2
XFILLER_7_413 VGND VGND VPWR VPWR sky130_fd_sc_hd__fill_1
XFILLER_7_446 VGND VGND VPWR VPWR sky130_fd_sc_hd__fill_2
XFILLER_109_396 VGND VGND VPWR VPWR sky130_fd_sc_hd__decap_3
XFILLER_99_87 VGND VGND VPWR VPWR sky130_fd_sc_hd__decap_3
XFILLER_3_652 VGND VGND VPWR VPWR sky130_fd_sc_hd__decap_3
XFILLER_112_539 VGND VGND VPWR VPWR sky130_fd_sc_hd__decap_3
XFILLER_2_184 VGND VGND VPWR VPWR sky130_fd_sc_hd__decap_3
XFILLER_66_604 VGND VGND VPWR VPWR sky130_fd_sc_hd__decap_3
XFILLER_66_637 VGND VGND VPWR VPWR sky130_fd_sc_hd__decap_3
XFILLER_17_6 VGND VGND VPWR VPWR sky130_fd_sc_hd__decap_3
XFILLER_65_125 VGND VGND VPWR VPWR sky130_fd_sc_hd__decap_3
XFILLER_66_648 VGND VGND VPWR VPWR sky130_fd_sc_hd__decap_3
XTAP_TAPCELL_ROW_49_835 VGND VPWR sky130_fd_sc_hd__tapvpwrvgnd_1
XFILLER_0_32 VGND VGND VPWR VPWR sky130_fd_sc_hd__decap_3
XFILLER_46_361 VGND VGND VPWR VPWR sky130_fd_sc_hd__decap_3
XFILLER_65_169 VGND VGND VPWR VPWR sky130_fd_sc_hd__decap_3
XFILLER_81_607 VGND VGND VPWR VPWR sky130_fd_sc_hd__decap_3
XFILLER_81_629 VGND VGND VPWR VPWR sky130_fd_sc_hd__decap_3
XFILLER_0_65 VGND VGND VPWR VPWR sky130_fd_sc_hd__decap_3
XFILLER_34_512 VGND VGND VPWR VPWR sky130_fd_sc_hd__decap_3
XFILLER_46_394 VGND VGND VPWR VPWR sky130_fd_sc_hd__decap_3
XFILLER_74_681 VGND VGND VPWR VPWR sky130_fd_sc_hd__decap_3
XFILLER_80_117 VGND VGND VPWR VPWR sky130_fd_sc_hd__decap_3
XFILLER_0_98 VGND VGND VPWR VPWR sky130_fd_sc_hd__decap_3
XFILLER_61_331 VGND VGND VPWR VPWR sky130_fd_sc_hd__decap_3
X_4800_ _7002_/Q _4826_/A _7003_/Q VGND VGND VPWR VPWR _4801_/B sky130_fd_sc_hd__a21oi_2
XFILLER_21_217 VGND VGND VPWR VPWR sky130_fd_sc_hd__decap_3
XFILLER_21_228 VGND VGND VPWR VPWR sky130_fd_sc_hd__decap_3
XFILLER_61_364 VGND VGND VPWR VPWR sky130_fd_sc_hd__fill_1
XFILLER_9_30 VGND VGND VPWR VPWR sky130_fd_sc_hd__decap_3
XFILLER_14_280 VGND VGND VPWR VPWR sky130_fd_sc_hd__decap_3
X_4731_ _4731_/A _4731_/B VGND VGND VPWR VPWR _7007_/D sky130_fd_sc_hd__and2_2
XFILLER_9_63 VGND VGND VPWR VPWR sky130_fd_sc_hd__decap_3
X_4662_ _4969_/B _4457_/X _4660_/X _4811_/C _4040_/Y VGND VGND VPWR VPWR _4662_/Y
+ sky130_fd_sc_hd__a221oi_2
XFILLER_9_96 VGND VGND VPWR VPWR sky130_fd_sc_hd__decap_3
X_6401_ _6562_/A VGND VGND VPWR VPWR _6401_/Y sky130_fd_sc_hd__inv_2
X_3613_ _3603_/Y _3606_/X _3612_/X VGND VGND VPWR VPWR _3614_/B sky130_fd_sc_hd__a21oi_2
X_7381_ _7383_/CLK _7381_/D _6661_/Y VGND VGND VPWR VPWR _7381_/Q sky130_fd_sc_hd__dfrtp_2
Xhold903 _7064_/Q VGND VGND VPWR VPWR _7064_/D sky130_fd_sc_hd__dlygate4sd3_1
X_4593_ _4593_/A _4595_/B VGND VGND VPWR VPWR _7284_/D sky130_fd_sc_hd__and2_2
Xhold914 _5678_/X VGND VGND VPWR VPWR _6689_/D sky130_fd_sc_hd__dlygate4sd3_1
Xhold925 _6697_/Q VGND VGND VPWR VPWR hold925/X sky130_fd_sc_hd__dlygate4sd3_1
Xhold936 _7021_/Q VGND VGND VPWR VPWR _5613_/A sky130_fd_sc_hd__dlygate4sd3_1
X_6332_ _6684_/A VGND VGND VPWR VPWR _6332_/Y sky130_fd_sc_hd__inv_2
X_3544_ _3544_/A _3544_/B VGND VGND VPWR VPWR _3635_/A sky130_fd_sc_hd__nor2_2
XFILLER_115_355 VGND VGND VPWR VPWR sky130_fd_sc_hd__decap_3
Xhold969 _7020_/Q VGND VGND VPWR VPWR _5615_/A sky130_fd_sc_hd__dlygate4sd3_1
Xhold958 _6690_/Q VGND VGND VPWR VPWR hold958/X sky130_fd_sc_hd__dlygate4sd3_1
Xhold947 _7029_/Q VGND VGND VPWR VPWR hold947/X sky130_fd_sc_hd__dlygate4sd3_1
X_6263_ _6385_/A VGND VGND VPWR VPWR _6263_/Y sky130_fd_sc_hd__inv_2
X_3475_ _7248_/Q _3358_/X _3472_/X _3474_/X VGND VGND VPWR VPWR _3502_/A sky130_fd_sc_hd__a211oi_2
XFILLER_115_399 VGND VGND VPWR VPWR sky130_fd_sc_hd__fill_2
XFILLER_111_561 VGND VGND VPWR VPWR sky130_fd_sc_hd__decap_3
XFILLER_57_615 VGND VGND VPWR VPWR sky130_fd_sc_hd__fill_1
XFILLER_57_626 VGND VGND VPWR VPWR sky130_fd_sc_hd__decap_3
XFILLER_69_464 VGND VGND VPWR VPWR sky130_fd_sc_hd__decap_3
XFILLER_69_475 VGND VGND VPWR VPWR sky130_fd_sc_hd__decap_3
XFILLER_84_412 VGND VGND VPWR VPWR sky130_fd_sc_hd__decap_3
XFILLER_96_272 VGND VGND VPWR VPWR sky130_fd_sc_hd__decap_3
X_5145_ _5145_/A _3500_/Y VGND VGND VPWR VPWR _5145_/X sky130_fd_sc_hd__or2b_2
XFILLER_111_594 VGND VGND VPWR VPWR sky130_fd_sc_hd__decap_3
XFILLER_56_125 VGND VGND VPWR VPWR sky130_fd_sc_hd__decap_3
XFILLER_57_659 VGND VGND VPWR VPWR sky130_fd_sc_hd__decap_3
XFILLER_96_294 VGND VGND VPWR VPWR sky130_fd_sc_hd__decap_3
XFILLER_25_501 VGND VGND VPWR VPWR sky130_fd_sc_hd__decap_3
XFILLER_44_309 VGND VGND VPWR VPWR sky130_fd_sc_hd__decap_3
XFILLER_71_106 VGND VGND VPWR VPWR sky130_fd_sc_hd__decap_3
XFILLER_84_489 VGND VGND VPWR VPWR sky130_fd_sc_hd__fill_2
XFILLER_25_556 VGND VGND VPWR VPWR sky130_fd_sc_hd__decap_3
XFILLER_44_27 VGND VGND VPWR VPWR sky130_fd_sc_hd__fill_1
XFILLER_44_49 VGND VGND VPWR VPWR sky130_fd_sc_hd__decap_3
XFILLER_52_342 VGND VGND VPWR VPWR sky130_fd_sc_hd__decap_3
XFILLER_80_651 VGND VGND VPWR VPWR sky130_fd_sc_hd__decap_3
XFILLER_12_206 VGND VGND VPWR VPWR sky130_fd_sc_hd__decap_3
XFILLER_25_578 VGND VGND VPWR VPWR sky130_fd_sc_hd__decap_3
XFILLER_80_684 VGND VGND VPWR VPWR sky130_fd_sc_hd__decap_3
XFILLER_100_22 VGND VGND VPWR VPWR sky130_fd_sc_hd__decap_3
XFILLER_100_55 VGND VGND VPWR VPWR sky130_fd_sc_hd__fill_1
X_4929_ _4908_/B _4928_/Y _5570_/A2 VGND VGND VPWR VPWR _4929_/Y sky130_fd_sc_hd__o21ai_2
XFILLER_60_15 VGND VGND VPWR VPWR sky130_fd_sc_hd__decap_3
XFILLER_60_48 VGND VGND VPWR VPWR sky130_fd_sc_hd__decap_3
XFILLER_109_42 VGND VGND VPWR VPWR sky130_fd_sc_hd__decap_3
XFILLER_4_427 VGND VGND VPWR VPWR sky130_fd_sc_hd__decap_3
XFILLER_109_75 VGND VGND VPWR VPWR sky130_fd_sc_hd__decap_3
XFILLER_69_24 VGND VGND VPWR VPWR sky130_fd_sc_hd__decap_3
XFILLER_69_57 VGND VGND VPWR VPWR sky130_fd_sc_hd__decap_3
XFILLER_106_377 VGND VGND VPWR VPWR sky130_fd_sc_hd__decap_3
XFILLER_79_228 VGND VGND VPWR VPWR sky130_fd_sc_hd__decap_3
XFILLER_48_604 VGND VGND VPWR VPWR sky130_fd_sc_hd__decap_3
XFILLER_85_23 VGND VGND VPWR VPWR sky130_fd_sc_hd__decap_3
XFILLER_87_272 VGND VGND VPWR VPWR sky130_fd_sc_hd__decap_3
XFILLER_94_209 VGND VGND VPWR VPWR sky130_fd_sc_hd__fill_1
XFILLER_102_594 VGND VGND VPWR VPWR sky130_fd_sc_hd__decap_3
XFILLER_47_125 VGND VGND VPWR VPWR sky130_fd_sc_hd__decap_3
XFILLER_48_637 VGND VGND VPWR VPWR sky130_fd_sc_hd__decap_3
XFILLER_48_648 VGND VGND VPWR VPWR sky130_fd_sc_hd__decap_3
XFILLER_75_423 VGND VGND VPWR VPWR sky130_fd_sc_hd__decap_3
XFILLER_85_45 VGND VGND VPWR VPWR sky130_fd_sc_hd__decap_3
XTAP_TAPCELL_ROW_89_1324 VGND VPWR sky130_fd_sc_hd__tapvpwrvgnd_1
XFILLER_18_61 VGND VGND VPWR VPWR sky130_fd_sc_hd__decap_3
XFILLER_63_607 VGND VGND VPWR VPWR sky130_fd_sc_hd__decap_3
XFILLER_63_629 VGND VGND VPWR VPWR sky130_fd_sc_hd__decap_3
XFILLER_75_478 VGND VGND VPWR VPWR sky130_fd_sc_hd__decap_3
XFILLER_90_404 VGND VGND VPWR VPWR sky130_fd_sc_hd__decap_3
XTAP_TAPCELL_ROW_46_805 VGND VPWR sky130_fd_sc_hd__tapvpwrvgnd_1
XFILLER_62_128 VGND VGND VPWR VPWR sky130_fd_sc_hd__decap_3
XFILLER_43_320 VGND VGND VPWR VPWR sky130_fd_sc_hd__decap_3
XFILLER_71_662 VGND VGND VPWR VPWR sky130_fd_sc_hd__decap_3
XFILLER_16_589 VGND VGND VPWR VPWR sky130_fd_sc_hd__decap_3
XFILLER_70_150 VGND VGND VPWR VPWR sky130_fd_sc_hd__decap_3
XFILLER_71_673 VGND VGND VPWR VPWR sky130_fd_sc_hd__decap_3
XTAP_TAPCELL_ROW_26_562 VGND VPWR sky130_fd_sc_hd__tapvpwrvgnd_1
XFILLER_34_82 VGND VGND VPWR VPWR sky130_fd_sc_hd__fill_2
XFILLER_86_9 VGND VGND VPWR VPWR sky130_fd_sc_hd__fill_2
XFILLER_7_265 VGND VGND VPWR VPWR sky130_fd_sc_hd__decap_3
XFILLER_50_70 VGND VGND VPWR VPWR sky130_fd_sc_hd__decap_3
XFILLER_50_81 VGND VGND VPWR VPWR sky130_fd_sc_hd__decap_3
XFILLER_109_193 VGND VGND VPWR VPWR sky130_fd_sc_hd__decap_3
XFILLER_39_615 VGND VGND VPWR VPWR sky130_fd_sc_hd__fill_1
XFILLER_66_412 VGND VGND VPWR VPWR sky130_fd_sc_hd__decap_3
XFILLER_15_3 VGND VGND VPWR VPWR sky130_fd_sc_hd__decap_3
XFILLER_78_294 VGND VGND VPWR VPWR sky130_fd_sc_hd__decap_3
XFILLER_93_220 VGND VGND VPWR VPWR sky130_fd_sc_hd__decap_3
XFILLER_26_309 VGND VGND VPWR VPWR sky130_fd_sc_hd__decap_3
XFILLER_38_147 VGND VGND VPWR VPWR sky130_fd_sc_hd__fill_2
XFILLER_54_607 VGND VGND VPWR VPWR sky130_fd_sc_hd__decap_3
XFILLER_66_467 VGND VGND VPWR VPWR sky130_fd_sc_hd__decap_3
XFILLER_81_404 VGND VGND VPWR VPWR sky130_fd_sc_hd__decap_3
XFILLER_93_264 VGND VGND VPWR VPWR sky130_fd_sc_hd__decap_3
X_6950_ _6976_/CLK _6950_/D VGND VGND VPWR VPWR _6950_/Q sky130_fd_sc_hd__dfxtp_2
XFILLER_19_372 VGND VGND VPWR VPWR sky130_fd_sc_hd__fill_1
XFILLER_19_383 VGND VGND VPWR VPWR sky130_fd_sc_hd__fill_1
XFILLER_53_128 VGND VGND VPWR VPWR sky130_fd_sc_hd__decap_3
XFILLER_53_139 VGND VGND VPWR VPWR sky130_fd_sc_hd__fill_1
XTAP_TAPCELL_ROW_109_1560 VGND VPWR sky130_fd_sc_hd__tapvpwrvgnd_1
XFILLER_46_191 VGND VGND VPWR VPWR sky130_fd_sc_hd__decap_3
XFILLER_62_640 VGND VGND VPWR VPWR sky130_fd_sc_hd__decap_3
XFILLER_62_651 VGND VGND VPWR VPWR sky130_fd_sc_hd__decap_3
X_6881_ _6972_/CLK _6881_/D VGND VGND VPWR VPWR _6881_/Q sky130_fd_sc_hd__dfxtp_2
XFILLER_62_684 VGND VGND VPWR VPWR sky130_fd_sc_hd__decap_3
XPHY_EDGE_ROW_101_Left_218 VGND VGND VPWR VPWR sky130_fd_sc_hd__decap_3
XFILLER_30_570 VGND VGND VPWR VPWR sky130_fd_sc_hd__decap_3
XFILLER_30_592 VGND VGND VPWR VPWR sky130_fd_sc_hd__decap_3
XFILLER_107_108 VGND VGND VPWR VPWR sky130_fd_sc_hd__decap_3
XFILLER_107_119 VGND VGND VPWR VPWR sky130_fd_sc_hd__decap_3
XFILLER_30_29 VGND VGND VPWR VPWR sky130_fd_sc_hd__decap_3
X_4645_ _4633_/X _4903_/B _4644_/X _4096_/A VGND VGND VPWR VPWR _4646_/B sky130_fd_sc_hd__o211a_2
XFILLER_116_620 VGND VGND VPWR VPWR sky130_fd_sc_hd__decap_3
X_7364_ _7364_/CLK _7364_/D _6644_/Y VGND VGND VPWR VPWR _7364_/Q sky130_fd_sc_hd__dfrtp_2
Xhold700 _6929_/Q VGND VGND VPWR VPWR _6929_/D sky130_fd_sc_hd__dlygate4sd3_1
Xhold711 _6902_/Q VGND VGND VPWR VPWR _6902_/D sky130_fd_sc_hd__dlygate4sd3_1
XFILLER_1_408 VGND VGND VPWR VPWR sky130_fd_sc_hd__decap_3
Xhold722 _6764_/Q VGND VGND VPWR VPWR _6764_/D sky130_fd_sc_hd__dlygate4sd3_1
Xhold733 _6956_/Q VGND VGND VPWR VPWR _6956_/D sky130_fd_sc_hd__dlygate4sd3_1
Xhold744 _6829_/Q VGND VGND VPWR VPWR _6829_/D sky130_fd_sc_hd__dlygate4sd3_1
Xhold755 _6910_/Q VGND VGND VPWR VPWR _6910_/D sky130_fd_sc_hd__dlygate4sd3_1
X_6315_ _6637_/A VGND VGND VPWR VPWR _6315_/Y sky130_fd_sc_hd__inv_2
X_3527_ _3527_/A _3427_/B VGND VGND VPWR VPWR _4614_/A sky130_fd_sc_hd__nor2b_2
XFILLER_115_152 VGND VGND VPWR VPWR sky130_fd_sc_hd__decap_3
XFILLER_89_548 VGND VGND VPWR VPWR sky130_fd_sc_hd__fill_1
X_7295_ _7364_/CLK _7295_/D _6575_/Y VGND VGND VPWR VPWR _7295_/Q sky130_fd_sc_hd__dfrtp_2
Xhold766 _6763_/Q VGND VGND VPWR VPWR _6763_/D sky130_fd_sc_hd__dlygate4sd3_1
Xhold777 _6965_/Q VGND VGND VPWR VPWR _6965_/D sky130_fd_sc_hd__dlygate4sd3_1
Xhold788 _6848_/Q VGND VGND VPWR VPWR _6848_/D sky130_fd_sc_hd__dlygate4sd3_1
XTAP_TAPCELL_ROW_73_1125 VGND VPWR sky130_fd_sc_hd__tapvpwrvgnd_1
XFILLER_115_196 VGND VGND VPWR VPWR sky130_fd_sc_hd__decap_3
Xhold799 _6839_/Q VGND VGND VPWR VPWR _6839_/D sky130_fd_sc_hd__dlygate4sd3_1
X_3458_ _3544_/A _3506_/B VGND VGND VPWR VPWR _3458_/Y sky130_fd_sc_hd__nor2_2
XPHY_EDGE_ROW_110_Left_227 VGND VGND VPWR VPWR sky130_fd_sc_hd__decap_3
XFILLER_97_570 VGND VGND VPWR VPWR sky130_fd_sc_hd__fill_1
X_3389_ _7347_/Q _4338_/B1 _3384_/X _3556_/A VGND VGND VPWR VPWR _3389_/X sky130_fd_sc_hd__a211o_2
XFILLER_111_391 VGND VGND VPWR VPWR sky130_fd_sc_hd__fill_1
XFILLER_69_272 VGND VGND VPWR VPWR sky130_fd_sc_hd__decap_3
X_5128_ _3733_/C _3904_/Y _4677_/B VGND VGND VPWR VPWR _5128_/Y sky130_fd_sc_hd__a21oi_2
XFILLER_29_169 VGND VGND VPWR VPWR sky130_fd_sc_hd__decap_3
XFILLER_45_607 VGND VGND VPWR VPWR sky130_fd_sc_hd__fill_1
XFILLER_55_15 VGND VGND VPWR VPWR sky130_fd_sc_hd__decap_3
XFILLER_84_264 VGND VGND VPWR VPWR sky130_fd_sc_hd__fill_2
XFILLER_38_681 VGND VGND VPWR VPWR sky130_fd_sc_hd__decap_3
XFILLER_45_629 VGND VGND VPWR VPWR sky130_fd_sc_hd__decap_3
XFILLER_57_489 VGND VGND VPWR VPWR sky130_fd_sc_hd__fill_2
X_5059_ _4832_/A _3859_/X _5662_/B VGND VGND VPWR VPWR _5059_/X sky130_fd_sc_hd__a21o_2
XFILLER_25_331 VGND VGND VPWR VPWR sky130_fd_sc_hd__decap_3
XFILLER_37_180 VGND VGND VPWR VPWR sky130_fd_sc_hd__decap_3
XFILLER_72_459 VGND VGND VPWR VPWR sky130_fd_sc_hd__decap_3
XFILLER_111_32 VGND VGND VPWR VPWR sky130_fd_sc_hd__decap_3
XFILLER_53_662 VGND VGND VPWR VPWR sky130_fd_sc_hd__decap_3
XFILLER_53_673 VGND VGND VPWR VPWR sky130_fd_sc_hd__decap_3
XTAP_TAPCELL_ROW_84_1265 VGND VPWR sky130_fd_sc_hd__tapvpwrvgnd_1
XTAP_TAPCELL_ROW_84_1254 VGND VPWR sky130_fd_sc_hd__tapvpwrvgnd_1
XFILLER_111_87 VGND VGND VPWR VPWR sky130_fd_sc_hd__decap_3
XFILLER_40_312 VGND VGND VPWR VPWR sky130_fd_sc_hd__decap_3
XFILLER_52_194 VGND VGND VPWR VPWR sky130_fd_sc_hd__fill_2
XFILLER_71_47 VGND VGND VPWR VPWR sky130_fd_sc_hd__decap_3
XFILLER_80_492 VGND VGND VPWR VPWR sky130_fd_sc_hd__decap_3
XTAP_TAPCELL_ROW_23_532 VGND VPWR sky130_fd_sc_hd__tapvpwrvgnd_1
XTAP_TAPCELL_ROW_51_863 VGND VPWR sky130_fd_sc_hd__tapvpwrvgnd_1
XPHY_EDGE_ROW_109_Right_109 VGND VGND VPWR VPWR sky130_fd_sc_hd__decap_3
XFILLER_107_620 VGND VGND VPWR VPWR sky130_fd_sc_hd__decap_3
XFILLER_106_141 VGND VGND VPWR VPWR sky130_fd_sc_hd__fill_2
XFILLER_107_653 VGND VGND VPWR VPWR sky130_fd_sc_hd__decap_3
XFILLER_20_40 VGND VGND VPWR VPWR sky130_fd_sc_hd__decap_3
XFILLER_106_174 VGND VGND VPWR VPWR sky130_fd_sc_hd__decap_3
XFILLER_20_73 VGND VGND VPWR VPWR sky130_fd_sc_hd__decap_3
XFILLER_4_268 VGND VGND VPWR VPWR sky130_fd_sc_hd__decap_3
XFILLER_96_11 VGND VGND VPWR VPWR sky130_fd_sc_hd__decap_3
XTAP_TAPCELL_ROW_95_1394 VGND VPWR sky130_fd_sc_hd__tapvpwrvgnd_1
XFILLER_0_430 VGND VGND VPWR VPWR sky130_fd_sc_hd__decap_3
XFILLER_96_44 VGND VGND VPWR VPWR sky130_fd_sc_hd__fill_2
XFILLER_0_452 VGND VGND VPWR VPWR sky130_fd_sc_hd__decap_3
XFILLER_48_401 VGND VGND VPWR VPWR sky130_fd_sc_hd__fill_2
XFILLER_29_60 VGND VGND VPWR VPWR sky130_fd_sc_hd__decap_3
XFILLER_96_88 VGND VGND VPWR VPWR sky130_fd_sc_hd__decap_3
XFILLER_29_93 VGND VGND VPWR VPWR sky130_fd_sc_hd__decap_3
XFILLER_36_618 VGND VGND VPWR VPWR sky130_fd_sc_hd__decap_3
XFILLER_75_242 VGND VGND VPWR VPWR sky130_fd_sc_hd__decap_3
XTAP_TAPCELL_ROW_59_963 VGND VPWR sky130_fd_sc_hd__tapvpwrvgnd_1
XFILLER_35_128 VGND VGND VPWR VPWR sky130_fd_sc_hd__decap_3
XFILLER_63_415 VGND VGND VPWR VPWR sky130_fd_sc_hd__decap_3
Xplace404 _4505_/S VGND VGND VPWR VPWR _4501_/S sky130_fd_sc_hd__buf_2
XFILLER_90_256 VGND VGND VPWR VPWR sky130_fd_sc_hd__decap_3
Xplace415 _4332_/B1 VGND VGND VPWR VPWR _4338_/B1 sky130_fd_sc_hd__buf_2
Xplace426 _4471_/S VGND VGND VPWR VPWR _4268_/A2 sky130_fd_sc_hd__buf_2
Xplace437 _3341_/A VGND VGND VPWR VPWR _4836_/S sky130_fd_sc_hd__buf_2
XTAP_TAPCELL_ROW_3_290 VGND VPWR sky130_fd_sc_hd__tapvpwrvgnd_1
XFILLER_44_673 VGND VGND VPWR VPWR sky130_fd_sc_hd__decap_3
XFILLER_71_470 VGND VGND VPWR VPWR sky130_fd_sc_hd__decap_3
Xplace448 _3318_/B VGND VGND VPWR VPWR _4469_/A3 sky130_fd_sc_hd__buf_2
Xplace459 _6980_/Q VGND VGND VPWR VPWR _3353_/A sky130_fd_sc_hd__buf_2
XFILLER_16_386 VGND VGND VPWR VPWR sky130_fd_sc_hd__decap_3
XFILLER_84_6 VGND VGND VPWR VPWR sky130_fd_sc_hd__decap_3
XFILLER_12_570 VGND VGND VPWR VPWR sky130_fd_sc_hd__decap_3
XFILLER_12_581 VGND VGND VPWR VPWR sky130_fd_sc_hd__decap_3
XFILLER_31_389 VGND VGND VPWR VPWR sky130_fd_sc_hd__decap_3
XFILLER_61_91 VGND VGND VPWR VPWR sky130_fd_sc_hd__decap_3
XFILLER_8_563 VGND VGND VPWR VPWR sky130_fd_sc_hd__decap_3
XANTENNA_2 _4571_/B VGND VGND VPWR VPWR sky130_fd_sc_hd__diode_2
X_4430_ _7239_/Q _4430_/A2 _4430_/B1 _7175_/Q _4429_/X VGND VGND VPWR VPWR _4430_/X
+ sky130_fd_sc_hd__a221o_2
XFILLER_6_53 VGND VGND VPWR VPWR sky130_fd_sc_hd__decap_3
XFILLER_112_100 VGND VGND VPWR VPWR sky130_fd_sc_hd__decap_3
XFILLER_113_612 VGND VGND VPWR VPWR sky130_fd_sc_hd__decap_3
XFILLER_113_623 VGND VGND VPWR VPWR sky130_fd_sc_hd__decap_3
XFILLER_6_97 VGND VGND VPWR VPWR sky130_fd_sc_hd__decap_3
X_4361_ _4361_/A _4619_/B _5101_/B _5073_/A VGND VGND VPWR VPWR _4361_/X sky130_fd_sc_hd__and4_2
XFILLER_112_133 VGND VGND VPWR VPWR sky130_fd_sc_hd__decap_3
XFILLER_113_656 VGND VGND VPWR VPWR sky130_fd_sc_hd__decap_3
X_7080_ _7363_/CLK _7080_/D _6360_/Y VGND VGND VPWR VPWR _7080_/Q sky130_fd_sc_hd__dfrtp_2
X_4292_ _4292_/A _4292_/B _4292_/C VGND VGND VPWR VPWR _4292_/X sky130_fd_sc_hd__and3_2
X_3312_ _6982_/Q _4467_/A _3519_/B _3310_/Y _5671_/A VGND VGND VPWR VPWR _5646_/A
+ sky130_fd_sc_hd__a311o_2
XFILLER_98_334 VGND VGND VPWR VPWR sky130_fd_sc_hd__decap_3
XFILLER_100_306 VGND VGND VPWR VPWR sky130_fd_sc_hd__fill_2
XFILLER_112_144 VGND VGND VPWR VPWR sky130_fd_sc_hd__decap_3
XFILLER_112_177 VGND VGND VPWR VPWR sky130_fd_sc_hd__decap_3
XFILLER_58_209 VGND VGND VPWR VPWR sky130_fd_sc_hd__decap_3
XFILLER_79_570 VGND VGND VPWR VPWR sky130_fd_sc_hd__decap_3
XFILLER_86_507 VGND VGND VPWR VPWR sky130_fd_sc_hd__decap_3
XFILLER_66_231 VGND VGND VPWR VPWR sky130_fd_sc_hd__decap_3
XFILLER_66_253 VGND VGND VPWR VPWR sky130_fd_sc_hd__decap_3
XFILLER_54_437 VGND VGND VPWR VPWR sky130_fd_sc_hd__decap_3
XFILLER_66_286 VGND VGND VPWR VPWR sky130_fd_sc_hd__fill_2
XFILLER_25_18 VGND VGND VPWR VPWR sky130_fd_sc_hd__fill_1
XFILLER_81_234 VGND VGND VPWR VPWR sky130_fd_sc_hd__decap_3
X_6933_ _7405_/CLK _6933_/D VGND VGND VPWR VPWR _6933_/Q sky130_fd_sc_hd__dfxtp_2
XFILLER_34_150 VGND VGND VPWR VPWR sky130_fd_sc_hd__decap_3
XFILLER_34_161 VGND VGND VPWR VPWR sky130_fd_sc_hd__decap_3
XFILLER_35_673 VGND VGND VPWR VPWR sky130_fd_sc_hd__decap_3
XFILLER_81_278 VGND VGND VPWR VPWR sky130_fd_sc_hd__fill_2
X_6864_ _6944_/CLK _6864_/D VGND VGND VPWR VPWR _6864_/Q sky130_fd_sc_hd__dfxtp_2
XFILLER_34_194 VGND VGND VPWR VPWR sky130_fd_sc_hd__fill_2
XFILLER_50_621 VGND VGND VPWR VPWR sky130_fd_sc_hd__decap_3
XFILLER_50_654 VGND VGND VPWR VPWR sky130_fd_sc_hd__decap_3
X_6795_ _7406_/CLK _6795_/D VGND VGND VPWR VPWR _6795_/Q sky130_fd_sc_hd__dfxtp_2
XFILLER_41_17 VGND VGND VPWR VPWR sky130_fd_sc_hd__decap_3
XFILLER_50_687 VGND VGND VPWR VPWR sky130_fd_sc_hd__decap_3
XFILLER_108_417 VGND VGND VPWR VPWR sky130_fd_sc_hd__decap_3
X_4628_ _4628_/A VGND VGND VPWR VPWR _4629_/A sky130_fd_sc_hd__inv_2
XFILLER_116_483 VGND VGND VPWR VPWR sky130_fd_sc_hd__decap_3
X_7347_ _7384_/CLK _7347_/D _6627_/Y VGND VGND VPWR VPWR _7347_/Q sky130_fd_sc_hd__dfrtp_2
X_4559_ _4559_/A _4563_/B VGND VGND VPWR VPWR _7301_/D sky130_fd_sc_hd__and2_2
XFILLER_103_122 VGND VGND VPWR VPWR sky130_fd_sc_hd__decap_3
XFILLER_104_634 VGND VGND VPWR VPWR sky130_fd_sc_hd__decap_3
XFILLER_104_645 VGND VGND VPWR VPWR sky130_fd_sc_hd__decap_3
XFILLER_89_334 VGND VGND VPWR VPWR sky130_fd_sc_hd__fill_2
X_7278_ _7310_/CLK _7278_/D _6558_/Y VGND VGND VPWR VPWR _7278_/Q sky130_fd_sc_hd__dfrtp_2
Xhold585 _6896_/Q VGND VGND VPWR VPWR _6896_/D sky130_fd_sc_hd__dlygate4sd3_1
Xhold596 _6908_/Q VGND VGND VPWR VPWR _6908_/D sky130_fd_sc_hd__dlygate4sd3_1
XFILLER_104_678 VGND VGND VPWR VPWR sky130_fd_sc_hd__decap_3
XFILLER_106_21 VGND VGND VPWR VPWR sky130_fd_sc_hd__decap_3
XFILLER_106_32 VGND VGND VPWR VPWR sky130_fd_sc_hd__decap_3
XFILLER_49_209 VGND VGND VPWR VPWR sky130_fd_sc_hd__decap_3
XFILLER_103_177 VGND VGND VPWR VPWR sky130_fd_sc_hd__decap_3
XFILLER_106_65 VGND VGND VPWR VPWR sky130_fd_sc_hd__decap_3
XFILLER_57_242 VGND VGND VPWR VPWR sky130_fd_sc_hd__decap_3
Xhold1230 _7289_/Q VGND VGND VPWR VPWR _4583_/A sky130_fd_sc_hd__dlygate4sd3_1
XFILLER_57_275 VGND VGND VPWR VPWR sky130_fd_sc_hd__decap_3
XTAP_TAPCELL_ROW_56_922 VGND VPWR sky130_fd_sc_hd__tapvpwrvgnd_1
XFILLER_82_24 VGND VGND VPWR VPWR sky130_fd_sc_hd__decap_3
XFILLER_82_35 VGND VGND VPWR VPWR sky130_fd_sc_hd__decap_3
XFILLER_13_323 VGND VGND VPWR VPWR sky130_fd_sc_hd__decap_3
XFILLER_25_183 VGND VGND VPWR VPWR sky130_fd_sc_hd__decap_3
XFILLER_82_68 VGND VGND VPWR VPWR sky130_fd_sc_hd__decap_3
XFILLER_13_345 VGND VGND VPWR VPWR sky130_fd_sc_hd__fill_1
XFILLER_15_51 VGND VGND VPWR VPWR sky130_fd_sc_hd__decap_3
XFILLER_40_131 VGND VGND VPWR VPWR sky130_fd_sc_hd__fill_1
XFILLER_41_665 VGND VGND VPWR VPWR sky130_fd_sc_hd__decap_3
XFILLER_41_676 VGND VGND VPWR VPWR sky130_fd_sc_hd__decap_3
XFILLER_40_164 VGND VGND VPWR VPWR sky130_fd_sc_hd__decap_3
XFILLER_9_349 VGND VGND VPWR VPWR sky130_fd_sc_hd__decap_3
XFILLER_40_197 VGND VGND VPWR VPWR sky130_fd_sc_hd__decap_3
XTAP_TAPCELL_ROW_97_1412 VGND VPWR sky130_fd_sc_hd__tapvpwrvgnd_1
XFILLER_5_522 VGND VGND VPWR VPWR sky130_fd_sc_hd__decap_3
XFILLER_31_72 VGND VGND VPWR VPWR sky130_fd_sc_hd__decap_3
XFILLER_31_94 VGND VGND VPWR VPWR sky130_fd_sc_hd__decap_3
XFILLER_107_472 VGND VGND VPWR VPWR sky130_fd_sc_hd__decap_3
XFILLER_5_588 VGND VGND VPWR VPWR sky130_fd_sc_hd__fill_2
XFILLER_49_9 VGND VGND VPWR VPWR sky130_fd_sc_hd__decap_3
XFILLER_110_604 VGND VGND VPWR VPWR sky130_fd_sc_hd__decap_3
XFILLER_110_637 VGND VGND VPWR VPWR sky130_fd_sc_hd__decap_3
XFILLER_110_648 VGND VGND VPWR VPWR sky130_fd_sc_hd__decap_3
XFILLER_95_337 VGND VGND VPWR VPWR sky130_fd_sc_hd__decap_3
XFILLER_48_253 VGND VGND VPWR VPWR sky130_fd_sc_hd__decap_3
XFILLER_95_359 VGND VGND VPWR VPWR sky130_fd_sc_hd__decap_3
XFILLER_36_415 VGND VGND VPWR VPWR sky130_fd_sc_hd__fill_1
XFILLER_76_584 VGND VGND VPWR VPWR sky130_fd_sc_hd__decap_3
XFILLER_36_448 VGND VGND VPWR VPWR sky130_fd_sc_hd__decap_3
XFILLER_48_297 VGND VGND VPWR VPWR sky130_fd_sc_hd__fill_2
XFILLER_63_223 VGND VGND VPWR VPWR sky130_fd_sc_hd__fill_1
XFILLER_63_234 VGND VGND VPWR VPWR sky130_fd_sc_hd__decap_3
XFILLER_63_245 VGND VGND VPWR VPWR sky130_fd_sc_hd__fill_2
XFILLER_91_554 VGND VGND VPWR VPWR sky130_fd_sc_hd__decap_3
XFILLER_17_673 VGND VGND VPWR VPWR sky130_fd_sc_hd__fill_2
XFILLER_63_267 VGND VGND VPWR VPWR sky130_fd_sc_hd__decap_3
Xplace289 _3886_/B1 VGND VGND VPWR VPWR _3907_/A2 sky130_fd_sc_hd__buf_2
Xplace278 _3661_/X VGND VGND VPWR VPWR _3892_/A2 sky130_fd_sc_hd__buf_2
Xplace267 _3925_/B1 VGND VGND VPWR VPWR _3767_/B1 sky130_fd_sc_hd__buf_2
XFILLER_31_175 VGND VGND VPWR VPWR sky130_fd_sc_hd__decap_3
XFILLER_32_687 VGND VGND VPWR VPWR sky130_fd_sc_hd__decap_3
XFILLER_82_3 VGND VGND VPWR VPWR sky130_fd_sc_hd__decap_3
X_6580_ _6610_/A VGND VGND VPWR VPWR _6580_/Y sky130_fd_sc_hd__inv_2
X_5600_ _5600_/A _5634_/B VGND VGND VPWR VPWR _7027_/D sky130_fd_sc_hd__and2_2
X_3792_ hold974/X _4466_/A _4961_/A VGND VGND VPWR VPWR _7392_/D sky130_fd_sc_hd__a21o_2
XFILLER_8_360 VGND VGND VPWR VPWR sky130_fd_sc_hd__decap_3
XFILLER_8_371 VGND VGND VPWR VPWR sky130_fd_sc_hd__fill_1
X_7201_ _7397_/CLK _7201_/D _6481_/Y VGND VGND VPWR VPWR _7201_/Q sky130_fd_sc_hd__dfrtp_2
X_4413_ _4413_/A VGND VGND VPWR VPWR _4787_/A sky130_fd_sc_hd__inv_2
X_7132_ _7294_/CLK _7132_/D _6412_/Y VGND VGND VPWR VPWR _7132_/Q sky130_fd_sc_hd__dfrtp_2
X_4344_ _4365_/A _4365_/B _4365_/C VGND VGND VPWR VPWR _4345_/B sky130_fd_sc_hd__a21bo_2
XFILLER_99_632 VGND VGND VPWR VPWR sky130_fd_sc_hd__decap_3
X_7063_ clkload7/A _7063_/D _6343_/Y VGND VGND VPWR VPWR _7063_/Q sky130_fd_sc_hd__dfrtp_2
XTAP_TAPCELL_ROW_6_319 VGND VPWR sky130_fd_sc_hd__tapvpwrvgnd_1
XFILLER_99_676 VGND VGND VPWR VPWR sky130_fd_sc_hd__decap_3
XFILLER_99_665 VGND VGND VPWR VPWR sky130_fd_sc_hd__decap_3
XFILLER_98_164 VGND VGND VPWR VPWR sky130_fd_sc_hd__decap_3
XFILLER_100_125 VGND VGND VPWR VPWR sky130_fd_sc_hd__decap_3
XFILLER_101_626 VGND VGND VPWR VPWR sky130_fd_sc_hd__decap_3
X_4275_ _4275_/A _4274_/Y VGND VGND VPWR VPWR _4620_/C sky130_fd_sc_hd__nor2b_2
XFILLER_98_197 VGND VGND VPWR VPWR sky130_fd_sc_hd__fill_1
XFILLER_101_659 VGND VGND VPWR VPWR sky130_fd_sc_hd__decap_3
XFILLER_39_231 VGND VGND VPWR VPWR sky130_fd_sc_hd__fill_1
XFILLER_39_275 VGND VGND VPWR VPWR sky130_fd_sc_hd__fill_2
XFILLER_54_212 VGND VGND VPWR VPWR sky130_fd_sc_hd__decap_3
XFILLER_82_554 VGND VGND VPWR VPWR sky130_fd_sc_hd__decap_3
XFILLER_94_381 VGND VGND VPWR VPWR sky130_fd_sc_hd__fill_1
XFILLER_54_256 VGND VGND VPWR VPWR sky130_fd_sc_hd__decap_3
XFILLER_54_278 VGND VGND VPWR VPWR sky130_fd_sc_hd__decap_3
XFILLER_82_587 VGND VGND VPWR VPWR sky130_fd_sc_hd__fill_1
XTAP_TAPCELL_ROW_68_1068 VGND VPWR sky130_fd_sc_hd__tapvpwrvgnd_1
XFILLER_42_429 VGND VGND VPWR VPWR sky130_fd_sc_hd__decap_3
XFILLER_82_598 VGND VGND VPWR VPWR sky130_fd_sc_hd__decap_3
X_6916_ _7386_/CLK _6916_/D VGND VGND VPWR VPWR _6916_/Q sky130_fd_sc_hd__dfxtp_2
XTAP_TAPCELL_ROW_81_1224 VGND VPWR sky130_fd_sc_hd__tapvpwrvgnd_1
XFILLER_52_38 VGND VGND VPWR VPWR sky130_fd_sc_hd__decap_3
X_6847_ _6978_/CLK _6847_/D VGND VGND VPWR VPWR _6847_/Q sky130_fd_sc_hd__dfxtp_2
XFILLER_10_315 VGND VGND VPWR VPWR sky130_fd_sc_hd__decap_3
XFILLER_22_175 VGND VGND VPWR VPWR sky130_fd_sc_hd__decap_3
X_6778_ _7383_/CLK _6778_/D VGND VGND VPWR VPWR _6778_/Q sky130_fd_sc_hd__dfxtp_2
XTAP_TAPCELL_ROW_61_980 VGND VPWR sky130_fd_sc_hd__tapvpwrvgnd_1
XFILLER_22_197 VGND VGND VPWR VPWR sky130_fd_sc_hd__decap_3
X_5729_ _7370_/Q hold950/X _5737_/S VGND VGND VPWR VPWR _6714_/D sky130_fd_sc_hd__mux2_2
XFILLER_108_203 VGND VGND VPWR VPWR sky130_fd_sc_hd__decap_3
XFILLER_2_514 VGND VGND VPWR VPWR sky130_fd_sc_hd__fill_1
XTAP_TAPCELL_ROW_79_1197 VGND VPWR sky130_fd_sc_hd__tapvpwrvgnd_1
XTAP_TAPCELL_ROW_92_1353 VGND VPWR sky130_fd_sc_hd__tapvpwrvgnd_1
XFILLER_104_453 VGND VGND VPWR VPWR sky130_fd_sc_hd__decap_3
XFILLER_77_304 VGND VGND VPWR VPWR sky130_fd_sc_hd__decap_3
XFILLER_77_35 VGND VGND VPWR VPWR sky130_fd_sc_hd__decap_3
XFILLER_77_337 VGND VGND VPWR VPWR sky130_fd_sc_hd__decap_3
XFILLER_77_57 VGND VGND VPWR VPWR sky130_fd_sc_hd__decap_3
XFILLER_77_79 VGND VGND VPWR VPWR sky130_fd_sc_hd__decap_3
XFILLER_100_681 VGND VGND VPWR VPWR sky130_fd_sc_hd__decap_3
XFILLER_18_415 VGND VGND VPWR VPWR sky130_fd_sc_hd__decap_3
XFILLER_58_584 VGND VGND VPWR VPWR sky130_fd_sc_hd__decap_3
XFILLER_58_595 VGND VGND VPWR VPWR sky130_fd_sc_hd__decap_3
XFILLER_85_370 VGND VGND VPWR VPWR sky130_fd_sc_hd__decap_3
XFILLER_92_329 VGND VGND VPWR VPWR sky130_fd_sc_hd__decap_3
XFILLER_93_12 VGND VGND VPWR VPWR sky130_fd_sc_hd__decap_3
Xhold1060 _7276_/Q VGND VGND VPWR VPWR _4753_/A0 sky130_fd_sc_hd__dlygate4sd3_1
XFILLER_45_223 VGND VGND VPWR VPWR sky130_fd_sc_hd__fill_1
XFILLER_73_554 VGND VGND VPWR VPWR sky130_fd_sc_hd__decap_3
Xhold1071 _7246_/Q VGND VGND VPWR VPWR _5163_/A sky130_fd_sc_hd__dlygate4sd3_1
Xhold1082 _7314_/Q VGND VGND VPWR VPWR _4530_/A0 sky130_fd_sc_hd__dlygate4sd3_1
Xhold1093 _7278_/Q VGND VGND VPWR VPWR _4718_/A0 sky130_fd_sc_hd__dlygate4sd3_1
XFILLER_33_407 VGND VGND VPWR VPWR sky130_fd_sc_hd__fill_1
XFILLER_45_256 VGND VGND VPWR VPWR sky130_fd_sc_hd__decap_3
XFILLER_45_278 VGND VGND VPWR VPWR sky130_fd_sc_hd__fill_2
XFILLER_73_587 VGND VGND VPWR VPWR sky130_fd_sc_hd__fill_1
XFILLER_13_142 VGND VGND VPWR VPWR sky130_fd_sc_hd__decap_3
XFILLER_14_654 VGND VGND VPWR VPWR sky130_fd_sc_hd__fill_1
XFILLER_26_94 VGND VGND VPWR VPWR sky130_fd_sc_hd__decap_3
XFILLER_60_259 VGND VGND VPWR VPWR sky130_fd_sc_hd__decap_3
XTAP_TAPCELL_ROW_31_619 VGND VPWR sky130_fd_sc_hd__tapvpwrvgnd_1
XTAP_TAPCELL_ROW_101_1460 VGND VPWR sky130_fd_sc_hd__tapvpwrvgnd_1
XFILLER_9_113 VGND VGND VPWR VPWR sky130_fd_sc_hd__decap_3
XFILLER_9_102 VGND VGND VPWR VPWR sky130_fd_sc_hd__decap_3
XFILLER_42_71 VGND VGND VPWR VPWR sky130_fd_sc_hd__decap_3
XTAP_TAPCELL_ROW_11_387 VGND VPWR sky130_fd_sc_hd__tapvpwrvgnd_1
XFILLER_114_206 VGND VGND VPWR VPWR sky130_fd_sc_hd__decap_3
XFILLER_114_239 VGND VGND VPWR VPWR sky130_fd_sc_hd__decap_3
XFILLER_47_6 VGND VGND VPWR VPWR sky130_fd_sc_hd__decap_3
XFILLER_5_396 VGND VGND VPWR VPWR sky130_fd_sc_hd__decap_3
XFILLER_3_21 VGND VGND VPWR VPWR sky130_fd_sc_hd__decap_3
XFILLER_68_304 VGND VGND VPWR VPWR sky130_fd_sc_hd__decap_3
XFILLER_3_54 VGND VGND VPWR VPWR sky130_fd_sc_hd__fill_2
XFILLER_95_101 VGND VGND VPWR VPWR sky130_fd_sc_hd__decap_3
XFILLER_96_635 VGND VGND VPWR VPWR sky130_fd_sc_hd__decap_3
XFILLER_1_591 VGND VGND VPWR VPWR sky130_fd_sc_hd__decap_3
XFILLER_3_87 VGND VGND VPWR VPWR sky130_fd_sc_hd__decap_3
XFILLER_96_657 VGND VGND VPWR VPWR sky130_fd_sc_hd__decap_3
X_4060_ _7084_/Q _4432_/A2 _4432_/B1 _4059_/X VGND VGND VPWR VPWR _4068_/A sky130_fd_sc_hd__o211a_2
XFILLER_95_178 VGND VGND VPWR VPWR sky130_fd_sc_hd__decap_3
XTAP_TAPCELL_ROW_39_719 VGND VPWR sky130_fd_sc_hd__tapvpwrvgnd_1
XFILLER_36_212 VGND VGND VPWR VPWR sky130_fd_sc_hd__decap_3
XFILLER_76_381 VGND VGND VPWR VPWR sky130_fd_sc_hd__decap_3
XFILLER_36_245 VGND VGND VPWR VPWR sky130_fd_sc_hd__fill_2
XFILLER_36_267 VGND VGND VPWR VPWR sky130_fd_sc_hd__decap_3
XFILLER_51_215 VGND VGND VPWR VPWR sky130_fd_sc_hd__decap_3
XFILLER_64_598 VGND VGND VPWR VPWR sky130_fd_sc_hd__decap_3
X_4962_ _6994_/Q _4977_/A VGND VGND VPWR VPWR _4963_/B sky130_fd_sc_hd__nor2_2
XTAP_TAPCELL_ROW_19_476 VGND VPWR sky130_fd_sc_hd__tapvpwrvgnd_1
X_6701_ _7392_/CLK _6701_/D VGND VGND VPWR VPWR _6701_/Q sky130_fd_sc_hd__dfxtp_2
X_4893_ _4928_/B _4943_/A _6996_/Q VGND VGND VPWR VPWR _4908_/B sky130_fd_sc_hd__o21a_2
X_3913_ _6857_/Q _3913_/A2 _3913_/B1 _6849_/Q _3912_/X VGND VGND VPWR VPWR _3913_/X
+ sky130_fd_sc_hd__a221o_2
X_6632_ _6632_/A VGND VGND VPWR VPWR _6632_/Y sky130_fd_sc_hd__inv_2
X_3844_ _3741_/X _3841_/X _3843_/X _3682_/A VGND VGND VPWR VPWR _3845_/B sky130_fd_sc_hd__a22o_2
X_6563_ _6599_/A VGND VGND VPWR VPWR _6563_/Y sky130_fd_sc_hd__inv_2
X_3775_ _3714_/X _3772_/X _3774_/X _3733_/X VGND VGND VPWR VPWR _3775_/X sky130_fd_sc_hd__a22o_2
XFILLER_8_190 VGND VGND VPWR VPWR sky130_fd_sc_hd__decap_3
X_6494_ _6651_/A VGND VGND VPWR VPWR _6494_/Y sky130_fd_sc_hd__inv_2
XFILLER_9_691 VGND VGND VPWR VPWR sky130_fd_sc_hd__fill_1
XTAP_TAPCELL_ROW_115_1629 VGND VPWR sky130_fd_sc_hd__tapvpwrvgnd_1
X_7115_ _7372_/CLK _7115_/D _6395_/Y VGND VGND VPWR VPWR _7115_/Q sky130_fd_sc_hd__dfrtp_2
Xoutput487 _5654_/Y VGND VGND VPWR VPWR alu_result_out[31] sky130_fd_sc_hd__clkdlybuf4s25_1
Xoutput476 _5656_/B VGND VGND VPWR VPWR alu_result_out[21] sky130_fd_sc_hd__clkdlybuf4s25_1
Xoutput465 _5662_/B VGND VGND VPWR VPWR alu_result_out[11] sky130_fd_sc_hd__clkdlybuf4s25_1
XFILLER_113_261 VGND VGND VPWR VPWR sky130_fd_sc_hd__decap_3
XFILLER_59_315 VGND VGND VPWR VPWR sky130_fd_sc_hd__decap_3
XFILLER_59_337 VGND VGND VPWR VPWR sky130_fd_sc_hd__fill_1
XFILLER_87_635 VGND VGND VPWR VPWR sky130_fd_sc_hd__decap_3
Xoutput498 _3525_/A VGND VGND VPWR VPWR instruction_out[13] sky130_fd_sc_hd__clkdlybuf4s25_1
X_4327_ _4327_/A _4327_/B VGND VGND VPWR VPWR _4362_/C sky130_fd_sc_hd__nand2_2
XFILLER_47_27 VGND VGND VPWR VPWR sky130_fd_sc_hd__decap_3
XFILLER_86_134 VGND VGND VPWR VPWR sky130_fd_sc_hd__decap_3
XFILLER_87_668 VGND VGND VPWR VPWR sky130_fd_sc_hd__decap_3
XFILLER_87_679 VGND VGND VPWR VPWR sky130_fd_sc_hd__decap_3
X_7046_ _7398_/CLK _7046_/D _6326_/Y VGND VGND VPWR VPWR _7046_/Q sky130_fd_sc_hd__dfrtp_2
X_4258_ _4988_/A _4988_/B VGND VGND VPWR VPWR _5003_/A sky130_fd_sc_hd__or2_4
XFILLER_27_201 VGND VGND VPWR VPWR sky130_fd_sc_hd__decap_3
XFILLER_47_49 VGND VGND VPWR VPWR sky130_fd_sc_hd__decap_3
XFILLER_74_307 VGND VGND VPWR VPWR sky130_fd_sc_hd__fill_1
XFILLER_103_33 VGND VGND VPWR VPWR sky130_fd_sc_hd__decap_3
XFILLER_27_234 VGND VGND VPWR VPWR sky130_fd_sc_hd__decap_3
X_4189_ _7231_/Q _4349_/B1 _4261_/B1 _7167_/Q _4188_/X VGND VGND VPWR VPWR _4189_/X
+ sky130_fd_sc_hd__a221o_2
XFILLER_103_55 VGND VGND VPWR VPWR sky130_fd_sc_hd__fill_1
XFILLER_70_502 VGND VGND VPWR VPWR sky130_fd_sc_hd__decap_3
XFILLER_82_362 VGND VGND VPWR VPWR sky130_fd_sc_hd__fill_2
XFILLER_70_513 VGND VGND VPWR VPWR sky130_fd_sc_hd__fill_2
XFILLER_82_373 VGND VGND VPWR VPWR sky130_fd_sc_hd__decap_3
XFILLER_42_259 VGND VGND VPWR VPWR sky130_fd_sc_hd__decap_3
XFILLER_10_112 VGND VGND VPWR VPWR sky130_fd_sc_hd__decap_3
XFILLER_50_292 VGND VGND VPWR VPWR sky130_fd_sc_hd__decap_3
XFILLER_109_501 VGND VGND VPWR VPWR sky130_fd_sc_hd__decap_3
XFILLER_11_679 VGND VGND VPWR VPWR sky130_fd_sc_hd__decap_3
XFILLER_7_617 VGND VGND VPWR VPWR sky130_fd_sc_hd__fill_2
XFILLER_109_545 VGND VGND VPWR VPWR sky130_fd_sc_hd__decap_3
XFILLER_109_567 VGND VGND VPWR VPWR sky130_fd_sc_hd__decap_3
XFILLER_12_41 VGND VGND VPWR VPWR sky130_fd_sc_hd__decap_3
XFILLER_6_127 VGND VGND VPWR VPWR sky130_fd_sc_hd__decap_3
XFILLER_12_74 VGND VGND VPWR VPWR sky130_fd_sc_hd__decap_3
XFILLER_12_85 VGND VGND VPWR VPWR sky130_fd_sc_hd__fill_2
XFILLER_88_12 VGND VGND VPWR VPWR sky130_fd_sc_hd__decap_3
XFILLER_2_300 VGND VGND VPWR VPWR sky130_fd_sc_hd__fill_2
XFILLER_88_45 VGND VGND VPWR VPWR sky130_fd_sc_hd__decap_3
XFILLER_2_344 VGND VGND VPWR VPWR sky130_fd_sc_hd__decap_3
XFILLER_104_250 VGND VGND VPWR VPWR sky130_fd_sc_hd__fill_2
XFILLER_2_377 VGND VGND VPWR VPWR sky130_fd_sc_hd__decap_3
XFILLER_77_101 VGND VGND VPWR VPWR sky130_fd_sc_hd__decap_3
XFILLER_78_657 VGND VGND VPWR VPWR sky130_fd_sc_hd__decap_3
XFILLER_92_115 VGND VGND VPWR VPWR sky130_fd_sc_hd__decap_3
XFILLER_93_638 VGND VGND VPWR VPWR sky130_fd_sc_hd__decap_3
XFILLER_18_223 VGND VGND VPWR VPWR sky130_fd_sc_hd__decap_3
XFILLER_37_60 VGND VGND VPWR VPWR sky130_fd_sc_hd__decap_3
XFILLER_86_690 VGND VGND VPWR VPWR sky130_fd_sc_hd__fill_2
XFILLER_37_82 VGND VGND VPWR VPWR sky130_fd_sc_hd__decap_3
XFILLER_37_93 VGND VGND VPWR VPWR sky130_fd_sc_hd__decap_3
XFILLER_73_340 VGND VGND VPWR VPWR sky130_fd_sc_hd__decap_3
XFILLER_92_159 VGND VGND VPWR VPWR sky130_fd_sc_hd__fill_2
XPHY_EDGE_ROW_16_Right_16 VGND VGND VPWR VPWR sky130_fd_sc_hd__decap_3
XFILLER_46_587 VGND VGND VPWR VPWR sky130_fd_sc_hd__fill_1
XFILLER_46_598 VGND VGND VPWR VPWR sky130_fd_sc_hd__fill_2
XFILLER_73_373 VGND VGND VPWR VPWR sky130_fd_sc_hd__decap_3
XFILLER_33_237 VGND VGND VPWR VPWR sky130_fd_sc_hd__decap_3
XTAP_TAPCELL_ROW_16_446 VGND VPWR sky130_fd_sc_hd__tapvpwrvgnd_1
XTAP_TAPCELL_ROW_44_777 VGND VPWR sky130_fd_sc_hd__tapvpwrvgnd_1
XFILLER_14_495 VGND VGND VPWR VPWR sky130_fd_sc_hd__decap_3
XFILLER_41_281 VGND VGND VPWR VPWR sky130_fd_sc_hd__decap_3
X_3560_ _5118_/D _3560_/B VGND VGND VPWR VPWR _3560_/Y sky130_fd_sc_hd__nor2_2
XPHY_EDGE_ROW_25_Right_25 VGND VGND VPWR VPWR sky130_fd_sc_hd__decap_3
XFILLER_6_661 VGND VGND VPWR VPWR sky130_fd_sc_hd__decap_3
XFILLER_115_526 VGND VGND VPWR VPWR sky130_fd_sc_hd__decap_3
XFILLER_115_559 VGND VGND VPWR VPWR sky130_fd_sc_hd__fill_1
X_3491_ _7215_/Q _4262_/A2 _3366_/X _7151_/Q _3490_/X VGND VGND VPWR VPWR _3491_/X
+ sky130_fd_sc_hd__a221o_2
XFILLER_45_3 VGND VGND VPWR VPWR sky130_fd_sc_hd__decap_3
XFILLER_68_112 VGND VGND VPWR VPWR sky130_fd_sc_hd__decap_3
XFILLER_69_635 VGND VGND VPWR VPWR sky130_fd_sc_hd__decap_3
X_5161_ _5161_/A _5641_/A VGND VGND VPWR VPWR _5221_/B sky130_fd_sc_hd__or2_2
XFILLER_110_231 VGND VGND VPWR VPWR sky130_fd_sc_hd__decap_3
XFILLER_69_668 VGND VGND VPWR VPWR sky130_fd_sc_hd__decap_3
XFILLER_69_679 VGND VGND VPWR VPWR sky130_fd_sc_hd__decap_3
X_5092_ _5069_/B _5092_/B _5092_/C VGND VGND VPWR VPWR _5092_/X sky130_fd_sc_hd__and3b_2
X_4112_ _7332_/Q _3962_/S _4505_/S _7300_/Q VGND VGND VPWR VPWR _4112_/X sky130_fd_sc_hd__a22o_2
XFILLER_56_318 VGND VGND VPWR VPWR sky130_fd_sc_hd__decap_3
XFILLER_56_329 VGND VGND VPWR VPWR sky130_fd_sc_hd__fill_1
XFILLER_68_167 VGND VGND VPWR VPWR sky130_fd_sc_hd__decap_3
XFILLER_84_616 VGND VGND VPWR VPWR sky130_fd_sc_hd__decap_3
X_4043_ _7309_/Q _4488_/S _4430_/B1 _7181_/Q _4042_/X VGND VGND VPWR VPWR _4043_/X
+ sky130_fd_sc_hd__a221o_2
XFILLER_110_286 VGND VGND VPWR VPWR sky130_fd_sc_hd__decap_3
XFILLER_49_370 VGND VGND VPWR VPWR sky130_fd_sc_hd__decap_3
XFILLER_83_137 VGND VGND VPWR VPWR sky130_fd_sc_hd__decap_3
XPHY_EDGE_ROW_34_Right_34 VGND VGND VPWR VPWR sky130_fd_sc_hd__decap_3
XFILLER_37_554 VGND VGND VPWR VPWR sky130_fd_sc_hd__fill_2
XFILLER_64_340 VGND VGND VPWR VPWR sky130_fd_sc_hd__decap_3
XFILLER_92_660 VGND VGND VPWR VPWR sky130_fd_sc_hd__decap_3
XFILLER_24_215 VGND VGND VPWR VPWR sky130_fd_sc_hd__decap_3
XFILLER_37_598 VGND VGND VPWR VPWR sky130_fd_sc_hd__decap_3
XTAP_TAPCELL_ROW_65_1027 VGND VPWR sky130_fd_sc_hd__tapvpwrvgnd_1
XFILLER_24_248 VGND VGND VPWR VPWR sky130_fd_sc_hd__decap_3
XFILLER_24_259 VGND VGND VPWR VPWR sky130_fd_sc_hd__decap_3
X_4945_ _3341_/A _6995_/D _5657_/C _4944_/X VGND VGND VPWR VPWR _4945_/X sky130_fd_sc_hd__o22a_2
XFILLER_20_421 VGND VGND VPWR VPWR sky130_fd_sc_hd__decap_3
XFILLER_20_443 VGND VGND VPWR VPWR sky130_fd_sc_hd__decap_3
XFILLER_20_465 VGND VGND VPWR VPWR sky130_fd_sc_hd__fill_1
X_6615_ _6619_/A VGND VGND VPWR VPWR _6615_/Y sky130_fd_sc_hd__inv_2
X_3827_ _6700_/Q _3887_/A2 _3925_/B1 _6878_/Q VGND VGND VPWR VPWR _3827_/X sky130_fd_sc_hd__a22o_2
XPHY_EDGE_ROW_43_Right_43 VGND VGND VPWR VPWR sky130_fd_sc_hd__decap_3
X_6546_ _6578_/A VGND VGND VPWR VPWR _6546_/Y sky130_fd_sc_hd__inv_2
XFILLER_3_108 VGND VGND VPWR VPWR sky130_fd_sc_hd__decap_3
XFILLER_106_548 VGND VGND VPWR VPWR sky130_fd_sc_hd__fill_2
XFILLER_3_119 VGND VGND VPWR VPWR sky130_fd_sc_hd__decap_3
X_6477_ _6608_/A VGND VGND VPWR VPWR _6477_/Y sky130_fd_sc_hd__inv_2
XTAP_TAPCELL_ROW_76_1167 VGND VPWR sky130_fd_sc_hd__tapvpwrvgnd_1
XFILLER_114_581 VGND VGND VPWR VPWR sky130_fd_sc_hd__decap_3
XFILLER_58_15 VGND VGND VPWR VPWR sky130_fd_sc_hd__decap_3
XFILLER_99_281 VGND VGND VPWR VPWR sky130_fd_sc_hd__decap_3
XFILLER_114_592 VGND VGND VPWR VPWR sky130_fd_sc_hd__decap_3
XFILLER_87_432 VGND VGND VPWR VPWR sky130_fd_sc_hd__decap_3
XFILLER_101_242 VGND VGND VPWR VPWR sky130_fd_sc_hd__fill_1
XFILLER_101_264 VGND VGND VPWR VPWR sky130_fd_sc_hd__decap_3
XFILLER_114_21 VGND VGND VPWR VPWR sky130_fd_sc_hd__decap_3
XFILLER_114_32 VGND VGND VPWR VPWR sky130_fd_sc_hd__decap_3
XFILLER_59_178 VGND VGND VPWR VPWR sky130_fd_sc_hd__decap_3
XFILLER_75_627 VGND VGND VPWR VPWR sky130_fd_sc_hd__decap_3
XFILLER_87_476 VGND VGND VPWR VPWR sky130_fd_sc_hd__fill_2
X_7029_ _7387_/CLK _7029_/D _6309_/Y VGND VGND VPWR VPWR _7029_/Q sky130_fd_sc_hd__dfrtp_2
XPHY_EDGE_ROW_52_Right_52 VGND VGND VPWR VPWR sky130_fd_sc_hd__decap_3
XFILLER_114_65 VGND VGND VPWR VPWR sky130_fd_sc_hd__decap_3
XFILLER_74_126 VGND VGND VPWR VPWR sky130_fd_sc_hd__decap_3
XFILLER_74_137 VGND VGND VPWR VPWR sky130_fd_sc_hd__decap_3
XFILLER_74_14 VGND VGND VPWR VPWR sky130_fd_sc_hd__fill_1
XFILLER_74_25 VGND VGND VPWR VPWR sky130_fd_sc_hd__decap_3
XFILLER_90_619 VGND VGND VPWR VPWR sky130_fd_sc_hd__decap_3
XFILLER_15_204 VGND VGND VPWR VPWR sky130_fd_sc_hd__decap_3
XFILLER_55_384 VGND VGND VPWR VPWR sky130_fd_sc_hd__fill_2
XFILLER_83_671 VGND VGND VPWR VPWR sky130_fd_sc_hd__fill_1
XFILLER_83_682 VGND VGND VPWR VPWR sky130_fd_sc_hd__fill_2
XTAP_TAPCELL_ROW_87_1296 VGND VPWR sky130_fd_sc_hd__tapvpwrvgnd_1
XFILLER_15_248 VGND VGND VPWR VPWR sky130_fd_sc_hd__decap_3
XFILLER_70_365 VGND VGND VPWR VPWR sky130_fd_sc_hd__decap_3
XTAP_TAPCELL_ROW_13_405 VGND VPWR sky130_fd_sc_hd__tapvpwrvgnd_1
XFILLER_11_421 VGND VGND VPWR VPWR sky130_fd_sc_hd__fill_1
XFILLER_23_270 VGND VGND VPWR VPWR sky130_fd_sc_hd__fill_2
XFILLER_23_281 VGND VGND VPWR VPWR sky130_fd_sc_hd__decap_3
XFILLER_51_590 VGND VGND VPWR VPWR sky130_fd_sc_hd__decap_3
XFILLER_70_398 VGND VGND VPWR VPWR sky130_fd_sc_hd__decap_3
XFILLER_90_79 VGND VGND VPWR VPWR sky130_fd_sc_hd__decap_3
XTAP_TAPCELL_ROW_41_747 VGND VPWR sky130_fd_sc_hd__tapvpwrvgnd_1
XPHY_EDGE_ROW_61_Right_61 VGND VGND VPWR VPWR sky130_fd_sc_hd__decap_3
XFILLER_23_51 VGND VGND VPWR VPWR sky130_fd_sc_hd__decap_3
XFILLER_23_84 VGND VGND VPWR VPWR sky130_fd_sc_hd__decap_3
XFILLER_7_425 VGND VGND VPWR VPWR sky130_fd_sc_hd__decap_3
XFILLER_7_458 VGND VGND VPWR VPWR sky130_fd_sc_hd__decap_3
XFILLER_109_364 VGND VGND VPWR VPWR sky130_fd_sc_hd__decap_3
XFILLER_109_375 VGND VGND VPWR VPWR sky130_fd_sc_hd__fill_1
XFILLER_99_44 VGND VGND VPWR VPWR sky130_fd_sc_hd__decap_3
XFILLER_99_33 VGND VGND VPWR VPWR sky130_fd_sc_hd__fill_1
XFILLER_99_66 VGND VGND VPWR VPWR sky130_fd_sc_hd__decap_3
XFILLER_2_130 VGND VGND VPWR VPWR sky130_fd_sc_hd__decap_3
XFILLER_3_631 VGND VGND VPWR VPWR sky130_fd_sc_hd__decap_3
XFILLER_3_664 VGND VGND VPWR VPWR sky130_fd_sc_hd__decap_3
XFILLER_99_99 VGND VGND VPWR VPWR sky130_fd_sc_hd__decap_3
XFILLER_105_570 VGND VGND VPWR VPWR sky130_fd_sc_hd__decap_3
XFILLER_112_518 VGND VGND VPWR VPWR sky130_fd_sc_hd__decap_3
XFILLER_2_141 VGND VGND VPWR VPWR sky130_fd_sc_hd__decap_3
XFILLER_31_9 VGND VGND VPWR VPWR sky130_fd_sc_hd__decap_3
XFILLER_78_410 VGND VGND VPWR VPWR sky130_fd_sc_hd__decap_3
XFILLER_78_421 VGND VGND VPWR VPWR sky130_fd_sc_hd__decap_3
XPHY_EDGE_ROW_70_Right_70 VGND VGND VPWR VPWR sky130_fd_sc_hd__decap_3
XFILLER_105_592 VGND VGND VPWR VPWR sky130_fd_sc_hd__decap_3
XFILLER_66_616 VGND VGND VPWR VPWR sky130_fd_sc_hd__decap_3
XFILLER_78_465 VGND VGND VPWR VPWR sky130_fd_sc_hd__decap_3
XFILLER_0_11 VGND VGND VPWR VPWR sky130_fd_sc_hd__decap_3
XFILLER_48_81 VGND VGND VPWR VPWR sky130_fd_sc_hd__decap_3
XFILLER_93_435 VGND VGND VPWR VPWR sky130_fd_sc_hd__decap_3
XTAP_TAPCELL_ROW_49_836 VGND VPWR sky130_fd_sc_hd__tapvpwrvgnd_1
XFILLER_0_44 VGND VGND VPWR VPWR sky130_fd_sc_hd__decap_3
XFILLER_65_159 VGND VGND VPWR VPWR sky130_fd_sc_hd__decap_3
XFILLER_74_660 VGND VGND VPWR VPWR sky130_fd_sc_hd__decap_3
XFILLER_93_468 VGND VGND VPWR VPWR sky130_fd_sc_hd__decap_3
XFILLER_0_77 VGND VGND VPWR VPWR sky130_fd_sc_hd__decap_3
XFILLER_19_587 VGND VGND VPWR VPWR sky130_fd_sc_hd__decap_3
XFILLER_34_502 VGND VGND VPWR VPWR sky130_fd_sc_hd__fill_2
XFILLER_61_310 VGND VGND VPWR VPWR sky130_fd_sc_hd__decap_3
XFILLER_80_129 VGND VGND VPWR VPWR sky130_fd_sc_hd__decap_3
XFILLER_61_343 VGND VGND VPWR VPWR sky130_fd_sc_hd__decap_3
XFILLER_64_91 VGND VGND VPWR VPWR sky130_fd_sc_hd__fill_2
XPHY_EDGE_ROW_14_Left_131 VGND VGND VPWR VPWR sky130_fd_sc_hd__decap_3
XFILLER_61_376 VGND VGND VPWR VPWR sky130_fd_sc_hd__fill_2
XFILLER_61_387 VGND VGND VPWR VPWR sky130_fd_sc_hd__decap_3
X_4730_ _7007_/Q _4738_/A VGND VGND VPWR VPWR _4731_/A sky130_fd_sc_hd__or2_2
XFILLER_9_42 VGND VGND VPWR VPWR sky130_fd_sc_hd__decap_3
XFILLER_9_75 VGND VGND VPWR VPWR sky130_fd_sc_hd__decap_3
X_7380_ clkload9/A _7380_/D _6660_/Y VGND VGND VPWR VPWR _7380_/Q sky130_fd_sc_hd__dfrtp_2
X_6400_ _6637_/A VGND VGND VPWR VPWR _6400_/Y sky130_fd_sc_hd__inv_2
X_3612_ _3536_/B _4614_/B _3610_/Y _3611_/Y VGND VGND VPWR VPWR _3612_/X sky130_fd_sc_hd__a211o_2
Xhold904 _7102_/Q VGND VGND VPWR VPWR _7102_/D sky130_fd_sc_hd__dlygate4sd3_1
X_6331_ _6682_/A VGND VGND VPWR VPWR _6331_/Y sky130_fd_sc_hd__inv_2
XFILLER_115_334 VGND VGND VPWR VPWR sky130_fd_sc_hd__fill_2
Xhold915 _6715_/Q VGND VGND VPWR VPWR hold915/X sky130_fd_sc_hd__dlygate4sd3_1
Xhold926 _6709_/Q VGND VGND VPWR VPWR hold926/X sky130_fd_sc_hd__dlygate4sd3_1
Xhold937 _6707_/Q VGND VGND VPWR VPWR hold937/X sky130_fd_sc_hd__dlygate4sd3_1
X_3543_ _3540_/X _3541_/X _5144_/A VGND VGND VPWR VPWR _3630_/B sky130_fd_sc_hd__o21ai_2
XFILLER_115_367 VGND VGND VPWR VPWR sky130_fd_sc_hd__decap_3
Xhold959 _7382_/Q VGND VGND VPWR VPWR hold959/X sky130_fd_sc_hd__dlygate4sd3_1
Xhold948 _7036_/Q VGND VGND VPWR VPWR hold948/X sky130_fd_sc_hd__dlygate4sd3_1
X_6262_ _6642_/A VGND VGND VPWR VPWR _6262_/Y sky130_fd_sc_hd__inv_2
X_3474_ _7280_/Q _4503_/S _4339_/B1 _7152_/Q _3473_/X VGND VGND VPWR VPWR _3474_/X
+ sky130_fd_sc_hd__a221o_2
XPHY_EDGE_ROW_23_Left_140 VGND VGND VPWR VPWR sky130_fd_sc_hd__decap_3
X_5213_ _7222_/Q _5221_/B VGND VGND VPWR VPWR _7222_/D sky130_fd_sc_hd__and2_2
X_5144_ _5144_/A _5144_/B VGND VGND VPWR VPWR _5145_/A sky130_fd_sc_hd__nand2_2
XFILLER_111_551 VGND VGND VPWR VPWR sky130_fd_sc_hd__decap_3
XFILLER_111_573 VGND VGND VPWR VPWR sky130_fd_sc_hd__decap_3
XFILLER_28_18 VGND VGND VPWR VPWR sky130_fd_sc_hd__decap_3
XFILLER_96_262 VGND VGND VPWR VPWR sky130_fd_sc_hd__fill_1
XFILLER_57_638 VGND VGND VPWR VPWR sky130_fd_sc_hd__decap_3
XFILLER_84_424 VGND VGND VPWR VPWR sky130_fd_sc_hd__decap_3
X_5075_ _5075_/A _5075_/B _5075_/C VGND VGND VPWR VPWR _5658_/A sky130_fd_sc_hd__or3_2
XFILLER_37_351 VGND VGND VPWR VPWR sky130_fd_sc_hd__fill_1
XFILLER_72_608 VGND VGND VPWR VPWR sky130_fd_sc_hd__fill_1
XFILLER_84_457 VGND VGND VPWR VPWR sky130_fd_sc_hd__decap_3
XFILLER_65_671 VGND VGND VPWR VPWR sky130_fd_sc_hd__fill_1
XFILLER_65_682 VGND VGND VPWR VPWR sky130_fd_sc_hd__decap_3
XFILLER_71_129 VGND VGND VPWR VPWR sky130_fd_sc_hd__decap_3
XFILLER_52_321 VGND VGND VPWR VPWR sky130_fd_sc_hd__decap_3
XFILLER_80_630 VGND VGND VPWR VPWR sky130_fd_sc_hd__decap_3
XFILLER_100_12 VGND VGND VPWR VPWR sky130_fd_sc_hd__fill_1
XFILLER_52_365 VGND VGND VPWR VPWR sky130_fd_sc_hd__decap_3
XFILLER_80_663 VGND VGND VPWR VPWR sky130_fd_sc_hd__decap_3
X_4928_ _6996_/Q _4928_/B _4943_/A VGND VGND VPWR VPWR _4928_/Y sky130_fd_sc_hd__nor3_2
XFILLER_20_251 VGND VGND VPWR VPWR sky130_fd_sc_hd__fill_1
XFILLER_60_27 VGND VGND VPWR VPWR sky130_fd_sc_hd__fill_1
X_4859_ _7000_/Q _4870_/A VGND VGND VPWR VPWR _4859_/Y sky130_fd_sc_hd__nor2_2
XFILLER_109_21 VGND VGND VPWR VPWR sky130_fd_sc_hd__decap_3
XFILLER_114_6 VGND VGND VPWR VPWR sky130_fd_sc_hd__decap_3
XFILLER_4_406 VGND VGND VPWR VPWR sky130_fd_sc_hd__decap_3
Xclkbuf_3_0__f_clk clkbuf_0_clk/X VGND VGND VPWR VPWR clkbuf_3_0__f_clk/X sky130_fd_sc_hd__clkbuf_16
XFILLER_109_54 VGND VGND VPWR VPWR sky130_fd_sc_hd__fill_2
XFILLER_4_439 VGND VGND VPWR VPWR sky130_fd_sc_hd__decap_3
X_6529_ _6562_/A VGND VGND VPWR VPWR _6529_/Y sky130_fd_sc_hd__inv_2
XFILLER_109_87 VGND VGND VPWR VPWR sky130_fd_sc_hd__decap_3
XFILLER_69_47 VGND VGND VPWR VPWR sky130_fd_sc_hd__fill_1
XFILLER_0_612 VGND VGND VPWR VPWR sky130_fd_sc_hd__decap_3
XFILLER_106_389 VGND VGND VPWR VPWR sky130_fd_sc_hd__decap_3
XFILLER_69_69 VGND VGND VPWR VPWR sky130_fd_sc_hd__decap_3
XFILLER_0_623 VGND VGND VPWR VPWR sky130_fd_sc_hd__decap_3
XFILLER_0_645 VGND VGND VPWR VPWR sky130_fd_sc_hd__decap_3
XFILLER_102_573 VGND VGND VPWR VPWR sky130_fd_sc_hd__decap_3
XFILLER_48_616 VGND VGND VPWR VPWR sky130_fd_sc_hd__decap_3
XFILLER_75_402 VGND VGND VPWR VPWR sky130_fd_sc_hd__decap_3
XFILLER_85_35 VGND VGND VPWR VPWR sky130_fd_sc_hd__decap_3
XFILLER_87_251 VGND VGND VPWR VPWR sky130_fd_sc_hd__decap_3
XFILLER_47_137 VGND VGND VPWR VPWR sky130_fd_sc_hd__decap_3
XFILLER_85_57 VGND VGND VPWR VPWR sky130_fd_sc_hd__decap_3
XFILLER_87_284 VGND VGND VPWR VPWR sky130_fd_sc_hd__decap_3
XTAP_TAPCELL_ROW_89_1325 VGND VPWR sky130_fd_sc_hd__tapvpwrvgnd_1
XTAP_TAPCELL_ROW_89_1314 VGND VPWR sky130_fd_sc_hd__tapvpwrvgnd_1
XFILLER_56_660 VGND VGND VPWR VPWR sky130_fd_sc_hd__decap_3
XFILLER_85_79 VGND VGND VPWR VPWR sky130_fd_sc_hd__decap_3
XTAP_TAPCELL_ROW_46_806 VGND VPWR sky130_fd_sc_hd__tapvpwrvgnd_1
XFILLER_16_524 VGND VGND VPWR VPWR sky130_fd_sc_hd__decap_3
XFILLER_28_373 VGND VGND VPWR VPWR sky130_fd_sc_hd__fill_2
XFILLER_56_671 VGND VGND VPWR VPWR sky130_fd_sc_hd__decap_3
XFILLER_62_107 VGND VGND VPWR VPWR sky130_fd_sc_hd__decap_3
XFILLER_90_427 VGND VGND VPWR VPWR sky130_fd_sc_hd__decap_3
XFILLER_43_332 VGND VGND VPWR VPWR sky130_fd_sc_hd__decap_3
XFILLER_55_192 VGND VGND VPWR VPWR sky130_fd_sc_hd__decap_3
XFILLER_71_641 VGND VGND VPWR VPWR sky130_fd_sc_hd__decap_3
XFILLER_90_449 VGND VGND VPWR VPWR sky130_fd_sc_hd__fill_2
XFILLER_16_568 VGND VGND VPWR VPWR sky130_fd_sc_hd__decap_3
XFILLER_70_162 VGND VGND VPWR VPWR sky130_fd_sc_hd__decap_3
XFILLER_71_685 VGND VGND VPWR VPWR sky130_fd_sc_hd__decap_3
XTAP_TAPCELL_ROW_26_563 VGND VPWR sky130_fd_sc_hd__tapvpwrvgnd_1
XFILLER_31_538 VGND VGND VPWR VPWR sky130_fd_sc_hd__decap_3
XFILLER_34_50 VGND VGND VPWR VPWR sky130_fd_sc_hd__fill_1
XFILLER_34_61 VGND VGND VPWR VPWR sky130_fd_sc_hd__decap_3
XFILLER_70_195 VGND VGND VPWR VPWR sky130_fd_sc_hd__fill_1
XTAP_TAPCELL_ROW_54_894 VGND VPWR sky130_fd_sc_hd__tapvpwrvgnd_1
XFILLER_11_240 VGND VGND VPWR VPWR sky130_fd_sc_hd__decap_3
XFILLER_34_94 VGND VGND VPWR VPWR sky130_fd_sc_hd__decap_3
XFILLER_11_273 VGND VGND VPWR VPWR sky130_fd_sc_hd__decap_3
XFILLER_11_284 VGND VGND VPWR VPWR sky130_fd_sc_hd__decap_3
XFILLER_116_109 VGND VGND VPWR VPWR sky130_fd_sc_hd__decap_3
XFILLER_109_161 VGND VGND VPWR VPWR sky130_fd_sc_hd__decap_3
XFILLER_7_277 VGND VGND VPWR VPWR sky130_fd_sc_hd__decap_3
XFILLER_112_304 VGND VGND VPWR VPWR sky130_fd_sc_hd__decap_3
XFILLER_3_461 VGND VGND VPWR VPWR sky130_fd_sc_hd__decap_3
XFILLER_98_527 VGND VGND VPWR VPWR sky130_fd_sc_hd__decap_3
XFILLER_38_126 VGND VGND VPWR VPWR sky130_fd_sc_hd__decap_3
XFILLER_66_424 VGND VGND VPWR VPWR sky130_fd_sc_hd__fill_1
XFILLER_66_446 VGND VGND VPWR VPWR sky130_fd_sc_hd__decap_3
XFILLER_54_619 VGND VGND VPWR VPWR sky130_fd_sc_hd__decap_3
XFILLER_47_671 VGND VGND VPWR VPWR sky130_fd_sc_hd__fill_1
XFILLER_47_682 VGND VGND VPWR VPWR sky130_fd_sc_hd__decap_3
XFILLER_81_416 VGND VGND VPWR VPWR sky130_fd_sc_hd__decap_3
XFILLER_93_276 VGND VGND VPWR VPWR sky130_fd_sc_hd__decap_3
XTAP_TAPCELL_ROW_109_1561 VGND VPWR sky130_fd_sc_hd__tapvpwrvgnd_1
XFILLER_46_181 VGND VGND VPWR VPWR sky130_fd_sc_hd__fill_2
XFILLER_74_490 VGND VGND VPWR VPWR sky130_fd_sc_hd__decap_3
XFILLER_81_449 VGND VGND VPWR VPWR sky130_fd_sc_hd__decap_3
X_6880_ _7392_/CLK _6880_/D VGND VGND VPWR VPWR _6880_/Q sky130_fd_sc_hd__dfxtp_2
XFILLER_61_151 VGND VGND VPWR VPWR sky130_fd_sc_hd__decap_3
XFILLER_62_663 VGND VGND VPWR VPWR sky130_fd_sc_hd__decap_3
XFILLER_22_527 VGND VGND VPWR VPWR sky130_fd_sc_hd__decap_3
X_4713_ _7008_/Q _4731_/B VGND VGND VPWR VPWR _7008_/D sky130_fd_sc_hd__xnor2_2
XFILLER_30_582 VGND VGND VPWR VPWR sky130_fd_sc_hd__fill_2
X_5693_ _7352_/Q hold920/X _5708_/S VGND VGND VPWR VPWR _6696_/D sky130_fd_sc_hd__mux2_2
X_4644_ _4111_/B _4643_/Y _4633_/A _4109_/X VGND VGND VPWR VPWR _4644_/X sky130_fd_sc_hd__a211o_2
X_7363_ _7363_/CLK _7363_/D _6643_/Y VGND VGND VPWR VPWR _7363_/Q sky130_fd_sc_hd__dfrtp_2
Xhold701 _6964_/Q VGND VGND VPWR VPWR _6964_/D sky130_fd_sc_hd__dlygate4sd3_1
Xhold712 _6740_/Q VGND VGND VPWR VPWR _6740_/D sky130_fd_sc_hd__dlygate4sd3_1
X_4575_ _4575_/A _4595_/B VGND VGND VPWR VPWR _7293_/D sky130_fd_sc_hd__and2_2
XFILLER_115_131 VGND VGND VPWR VPWR sky130_fd_sc_hd__decap_3
XFILLER_116_654 VGND VGND VPWR VPWR sky130_fd_sc_hd__decap_3
XFILLER_89_505 VGND VGND VPWR VPWR sky130_fd_sc_hd__fill_2
X_7294_ _7294_/CLK _7294_/D _6574_/Y VGND VGND VPWR VPWR _7294_/Q sky130_fd_sc_hd__dfrtp_2
Xhold723 _6793_/Q VGND VGND VPWR VPWR _6793_/D sky130_fd_sc_hd__dlygate4sd3_1
Xhold734 _6752_/Q VGND VGND VPWR VPWR _6752_/D sky130_fd_sc_hd__dlygate4sd3_1
Xhold745 _6853_/Q VGND VGND VPWR VPWR _6853_/D sky130_fd_sc_hd__dlygate4sd3_1
X_6314_ _6634_/A VGND VGND VPWR VPWR _6314_/Y sky130_fd_sc_hd__inv_2
X_3526_ _4938_/A _3526_/B VGND VGND VPWR VPWR _5057_/A sky130_fd_sc_hd__nand2_2
XFILLER_115_164 VGND VGND VPWR VPWR sky130_fd_sc_hd__decap_3
XFILLER_115_175 VGND VGND VPWR VPWR sky130_fd_sc_hd__decap_3
XFILLER_116_676 VGND VGND VPWR VPWR sky130_fd_sc_hd__decap_3
XFILLER_89_516 VGND VGND VPWR VPWR sky130_fd_sc_hd__fill_1
XFILLER_89_527 VGND VGND VPWR VPWR sky130_fd_sc_hd__decap_3
Xhold756 _6880_/Q VGND VGND VPWR VPWR _6880_/D sky130_fd_sc_hd__dlygate4sd3_1
Xhold767 _6744_/Q VGND VGND VPWR VPWR _6744_/D sky130_fd_sc_hd__dlygate4sd3_1
Xhold778 _6776_/Q VGND VGND VPWR VPWR _6776_/D sky130_fd_sc_hd__dlygate4sd3_1
XTAP_TAPCELL_ROW_73_1126 VGND VPWR sky130_fd_sc_hd__tapvpwrvgnd_1
XFILLER_39_39 VGND VGND VPWR VPWR sky130_fd_sc_hd__fill_1
Xhold789 _6759_/Q VGND VGND VPWR VPWR _6759_/D sky130_fd_sc_hd__dlygate4sd3_1
X_3457_ _4394_/A _3449_/C _3424_/S _3456_/X VGND VGND VPWR VPWR _3506_/B sky130_fd_sc_hd__a22o_2
XFILLER_69_240 VGND VGND VPWR VPWR sky130_fd_sc_hd__decap_3
X_3388_ _3394_/A _3429_/B VGND VGND VPWR VPWR _3388_/Y sky130_fd_sc_hd__nor2_2
XFILLER_69_284 VGND VGND VPWR VPWR sky130_fd_sc_hd__decap_3
XFILLER_84_210 VGND VGND VPWR VPWR sky130_fd_sc_hd__decap_3
XFILLER_29_148 VGND VGND VPWR VPWR sky130_fd_sc_hd__decap_3
XFILLER_57_446 VGND VGND VPWR VPWR sky130_fd_sc_hd__fill_2
XFILLER_84_232 VGND VGND VPWR VPWR sky130_fd_sc_hd__decap_3
X_5058_ _5072_/A _4330_/B _5056_/X _5057_/Y VGND VGND VPWR VPWR _5662_/B sky130_fd_sc_hd__a211o_2
XPHY_EDGE_ROW_2_Right_2 VGND VGND VPWR VPWR sky130_fd_sc_hd__decap_3
XFILLER_38_660 VGND VGND VPWR VPWR sky130_fd_sc_hd__decap_3
XFILLER_44_118 VGND VGND VPWR VPWR sky130_fd_sc_hd__decap_3
XFILLER_55_27 VGND VGND VPWR VPWR sky130_fd_sc_hd__fill_2
XFILLER_72_405 VGND VGND VPWR VPWR sky130_fd_sc_hd__decap_3
XFILLER_72_427 VGND VGND VPWR VPWR sky130_fd_sc_hd__decap_3
XFILLER_25_343 VGND VGND VPWR VPWR sky130_fd_sc_hd__decap_3
XFILLER_37_192 VGND VGND VPWR VPWR sky130_fd_sc_hd__decap_3
XFILLER_53_641 VGND VGND VPWR VPWR sky130_fd_sc_hd__decap_3
XFILLER_111_44 VGND VGND VPWR VPWR sky130_fd_sc_hd__decap_3
XFILLER_13_505 VGND VGND VPWR VPWR sky130_fd_sc_hd__decap_3
XTAP_TAPCELL_ROW_84_1255 VGND VPWR sky130_fd_sc_hd__tapvpwrvgnd_1
XFILLER_111_66 VGND VGND VPWR VPWR sky130_fd_sc_hd__decap_3
XFILLER_40_324 VGND VGND VPWR VPWR sky130_fd_sc_hd__decap_3
XFILLER_52_184 VGND VGND VPWR VPWR sky130_fd_sc_hd__decap_3
XFILLER_71_15 VGND VGND VPWR VPWR sky130_fd_sc_hd__decap_3
XTAP_TAPCELL_ROW_23_522 VGND VPWR sky130_fd_sc_hd__tapvpwrvgnd_1
XFILLER_111_99 VGND VGND VPWR VPWR sky130_fd_sc_hd__decap_3
XTAP_TAPCELL_ROW_51_864 VGND VPWR sky130_fd_sc_hd__tapvpwrvgnd_1
XTAP_TAPCELL_ROW_23_533 VGND VPWR sky130_fd_sc_hd__tapvpwrvgnd_1
XFILLER_107_610 VGND VGND VPWR VPWR sky130_fd_sc_hd__decap_3
XFILLER_107_632 VGND VGND VPWR VPWR sky130_fd_sc_hd__decap_3
XFILLER_106_120 VGND VGND VPWR VPWR sky130_fd_sc_hd__decap_3
XFILLER_107_665 VGND VGND VPWR VPWR sky130_fd_sc_hd__decap_3
XFILLER_20_52 VGND VGND VPWR VPWR sky130_fd_sc_hd__decap_3
XFILLER_106_164 VGND VGND VPWR VPWR sky130_fd_sc_hd__decap_3
XFILLER_107_676 VGND VGND VPWR VPWR sky130_fd_sc_hd__decap_3
XFILLER_20_85 VGND VGND VPWR VPWR sky130_fd_sc_hd__decap_3
XTAP_TAPCELL_ROW_95_1395 VGND VPWR sky130_fd_sc_hd__tapvpwrvgnd_1
XFILLER_106_197 VGND VGND VPWR VPWR sky130_fd_sc_hd__decap_3
XFILLER_96_23 VGND VGND VPWR VPWR sky130_fd_sc_hd__decap_3
XFILLER_0_464 VGND VGND VPWR VPWR sky130_fd_sc_hd__decap_3
XFILLER_96_56 VGND VGND VPWR VPWR sky130_fd_sc_hd__decap_3
XFILLER_48_413 VGND VGND VPWR VPWR sky130_fd_sc_hd__decap_3
XFILLER_75_221 VGND VGND VPWR VPWR sky130_fd_sc_hd__decap_3
XTAP_TAPCELL_ROW_59_964 VGND VPWR sky130_fd_sc_hd__tapvpwrvgnd_1
XFILLER_75_287 VGND VGND VPWR VPWR sky130_fd_sc_hd__decap_3
XFILLER_90_213 VGND VGND VPWR VPWR sky130_fd_sc_hd__decap_3
XFILLER_16_321 VGND VGND VPWR VPWR sky130_fd_sc_hd__decap_3
XFILLER_44_641 VGND VGND VPWR VPWR sky130_fd_sc_hd__decap_3
XFILLER_63_438 VGND VGND VPWR VPWR sky130_fd_sc_hd__decap_3
XFILLER_90_235 VGND VGND VPWR VPWR sky130_fd_sc_hd__decap_3
Xplace405 _4482_/S VGND VGND VPWR VPWR _4488_/S sky130_fd_sc_hd__buf_2
Xplace416 _3380_/Y VGND VGND VPWR VPWR _4332_/B1 sky130_fd_sc_hd__buf_2
Xplace427 _3989_/S VGND VGND VPWR VPWR _3987_/S sky130_fd_sc_hd__buf_2
Xplace438 _5581_/S VGND VGND VPWR VPWR _5595_/B sky130_fd_sc_hd__buf_2
XTAP_TAPCELL_ROW_3_291 VGND VPWR sky130_fd_sc_hd__tapvpwrvgnd_1
XFILLER_44_685 VGND VGND VPWR VPWR sky130_fd_sc_hd__decap_3
XFILLER_90_268 VGND VGND VPWR VPWR sky130_fd_sc_hd__decap_3
Xplace449 _3332_/B VGND VGND VPWR VPWR _3318_/B sky130_fd_sc_hd__buf_2
XFILLER_16_398 VGND VGND VPWR VPWR sky130_fd_sc_hd__decap_3
XFILLER_71_482 VGND VGND VPWR VPWR sky130_fd_sc_hd__fill_1
XFILLER_31_368 VGND VGND VPWR VPWR sky130_fd_sc_hd__decap_3
XFILLER_61_70 VGND VGND VPWR VPWR sky130_fd_sc_hd__fill_2
XFILLER_77_6 VGND VGND VPWR VPWR sky130_fd_sc_hd__decap_3
XANTENNA_3 _5663_/A VGND VGND VPWR VPWR sky130_fd_sc_hd__diode_2
XFILLER_6_21 VGND VGND VPWR VPWR sky130_fd_sc_hd__decap_3
XFILLER_6_32 VGND VGND VPWR VPWR sky130_fd_sc_hd__decap_3
XFILLER_6_65 VGND VGND VPWR VPWR sky130_fd_sc_hd__decap_3
X_4360_ _5072_/B _5071_/B VGND VGND VPWR VPWR _5073_/A sky130_fd_sc_hd__nand2_2
X_3311_ _5118_/C _4696_/B _3340_/B VGND VGND VPWR VPWR _5671_/A sky130_fd_sc_hd__o21ai_2
XFILLER_112_112 VGND VGND VPWR VPWR sky130_fd_sc_hd__decap_3
XFILLER_113_635 VGND VGND VPWR VPWR sky130_fd_sc_hd__decap_3
X_4291_ _4612_/A _4612_/B VGND VGND VPWR VPWR _4292_/C sky130_fd_sc_hd__xnor2_2
XFILLER_112_156 VGND VGND VPWR VPWR sky130_fd_sc_hd__decap_3
XFILLER_113_668 VGND VGND VPWR VPWR sky130_fd_sc_hd__decap_3
XFILLER_113_679 VGND VGND VPWR VPWR sky130_fd_sc_hd__decap_3
XFILLER_98_368 VGND VGND VPWR VPWR sky130_fd_sc_hd__decap_3
XFILLER_100_329 VGND VGND VPWR VPWR sky130_fd_sc_hd__decap_3
XFILLER_112_189 VGND VGND VPWR VPWR sky130_fd_sc_hd__decap_3
XFILLER_39_446 VGND VGND VPWR VPWR sky130_fd_sc_hd__fill_2
XFILLER_66_243 VGND VGND VPWR VPWR sky130_fd_sc_hd__fill_1
XFILLER_39_479 VGND VGND VPWR VPWR sky130_fd_sc_hd__decap_3
XFILLER_54_416 VGND VGND VPWR VPWR sky130_fd_sc_hd__decap_3
XFILLER_54_427 VGND VGND VPWR VPWR sky130_fd_sc_hd__fill_1
XFILLER_66_265 VGND VGND VPWR VPWR sky130_fd_sc_hd__decap_3
XFILLER_19_181 VGND VGND VPWR VPWR sky130_fd_sc_hd__decap_3
XFILLER_81_246 VGND VGND VPWR VPWR sky130_fd_sc_hd__decap_3
X_6932_ _7392_/CLK _6932_/D VGND VGND VPWR VPWR _6932_/Q sky130_fd_sc_hd__dfxtp_2
XFILLER_50_600 VGND VGND VPWR VPWR sky130_fd_sc_hd__decap_3
X_6863_ _6909_/CLK _6863_/D VGND VGND VPWR VPWR _6863_/Q sky130_fd_sc_hd__dfxtp_2
XFILLER_22_324 VGND VGND VPWR VPWR sky130_fd_sc_hd__decap_3
XFILLER_34_173 VGND VGND VPWR VPWR sky130_fd_sc_hd__decap_3
XFILLER_50_633 VGND VGND VPWR VPWR sky130_fd_sc_hd__decap_3
XFILLER_10_508 VGND VGND VPWR VPWR sky130_fd_sc_hd__decap_3
XFILLER_22_346 VGND VGND VPWR VPWR sky130_fd_sc_hd__decap_3
XFILLER_50_666 VGND VGND VPWR VPWR sky130_fd_sc_hd__decap_3
X_6794_ clkload2/A _6794_/D VGND VGND VPWR VPWR _6794_/Q sky130_fd_sc_hd__dfxtp_2
XFILLER_41_29 VGND VGND VPWR VPWR sky130_fd_sc_hd__decap_3
XFILLER_108_407 VGND VGND VPWR VPWR sky130_fd_sc_hd__decap_3
X_5676_ _7344_/Q hold910/X _5706_/S VGND VGND VPWR VPWR _6688_/D sky130_fd_sc_hd__mux2_2
X_4627_ _4627_/A VGND VGND VPWR VPWR _4627_/Y sky130_fd_sc_hd__inv_2
XFILLER_104_613 VGND VGND VPWR VPWR sky130_fd_sc_hd__decap_3
XFILLER_116_462 VGND VGND VPWR VPWR sky130_fd_sc_hd__decap_3
X_7346_ clkload9/A _7346_/D _6626_/Y VGND VGND VPWR VPWR _7346_/Q sky130_fd_sc_hd__dfrtp_2
XFILLER_103_101 VGND VGND VPWR VPWR sky130_fd_sc_hd__decap_3
XFILLER_104_657 VGND VGND VPWR VPWR sky130_fd_sc_hd__decap_3
XFILLER_89_346 VGND VGND VPWR VPWR sky130_fd_sc_hd__decap_3
X_7277_ _7310_/CLK _7277_/D _6557_/Y VGND VGND VPWR VPWR _7277_/Q sky130_fd_sc_hd__dfrtp_2
Xhold586 _6808_/Q VGND VGND VPWR VPWR _6808_/D sky130_fd_sc_hd__dlygate4sd3_1
Xhold597 _6807_/Q VGND VGND VPWR VPWR _6807_/D sky130_fd_sc_hd__dlygate4sd3_1
X_3509_ _5640_/B _3509_/B VGND VGND VPWR VPWR _3509_/Y sky130_fd_sc_hd__nor2_2
XFILLER_9_9 VGND VGND VPWR VPWR sky130_fd_sc_hd__decap_3
XFILLER_103_145 VGND VGND VPWR VPWR sky130_fd_sc_hd__fill_2
XFILLER_106_44 VGND VGND VPWR VPWR sky130_fd_sc_hd__decap_3
XFILLER_77_508 VGND VGND VPWR VPWR sky130_fd_sc_hd__decap_3
XFILLER_106_77 VGND VGND VPWR VPWR sky130_fd_sc_hd__decap_3
XFILLER_112_690 VGND VGND VPWR VPWR sky130_fd_sc_hd__fill_2
XFILLER_57_210 VGND VGND VPWR VPWR sky130_fd_sc_hd__decap_3
XFILLER_66_15 VGND VGND VPWR VPWR sky130_fd_sc_hd__decap_3
XFILLER_57_221 VGND VGND VPWR VPWR sky130_fd_sc_hd__decap_3
XFILLER_57_254 VGND VGND VPWR VPWR sky130_fd_sc_hd__decap_3
XFILLER_66_48 VGND VGND VPWR VPWR sky130_fd_sc_hd__decap_3
XFILLER_85_541 VGND VGND VPWR VPWR sky130_fd_sc_hd__decap_3
XFILLER_97_390 VGND VGND VPWR VPWR sky130_fd_sc_hd__fill_2
Xhold1220 _7324_/Q VGND VGND VPWR VPWR _4510_/A0 sky130_fd_sc_hd__dlygate4sd3_1
Xhold1231 _7125_/Q VGND VGND VPWR VPWR _5417_/A0 sky130_fd_sc_hd__dlygate4sd3_1
XFILLER_17_107 VGND VGND VPWR VPWR sky130_fd_sc_hd__decap_3
XFILLER_18_619 VGND VGND VPWR VPWR sky130_fd_sc_hd__decap_3
XFILLER_45_405 VGND VGND VPWR VPWR sky130_fd_sc_hd__decap_3
XFILLER_57_287 VGND VGND VPWR VPWR sky130_fd_sc_hd__decap_3
XFILLER_85_596 VGND VGND VPWR VPWR sky130_fd_sc_hd__decap_3
XTAP_TAPCELL_ROW_56_923 VGND VPWR sky130_fd_sc_hd__tapvpwrvgnd_1
XFILLER_45_438 VGND VGND VPWR VPWR sky130_fd_sc_hd__decap_3
XFILLER_45_449 VGND VGND VPWR VPWR sky130_fd_sc_hd__fill_2
XFILLER_72_246 VGND VGND VPWR VPWR sky130_fd_sc_hd__decap_3
Xclkbuf_leaf_37_clk clkbuf_leaf_1_clk/A VGND VGND VPWR VPWR _7383_/CLK sky130_fd_sc_hd__clkbuf_16
XFILLER_25_140 VGND VGND VPWR VPWR sky130_fd_sc_hd__decap_3
XFILLER_25_151 VGND VGND VPWR VPWR sky130_fd_sc_hd__decap_3
XFILLER_72_268 VGND VGND VPWR VPWR sky130_fd_sc_hd__fill_2
XFILLER_82_47 VGND VGND VPWR VPWR sky130_fd_sc_hd__decap_3
XTAP_TAPCELL_ROW_0_250 VGND VPWR sky130_fd_sc_hd__tapvpwrvgnd_1
XFILLER_15_30 VGND VGND VPWR VPWR sky130_fd_sc_hd__decap_3
XFILLER_53_471 VGND VGND VPWR VPWR sky130_fd_sc_hd__decap_3
XTAP_TAPCELL_ROW_36_680 VGND VPWR sky130_fd_sc_hd__tapvpwrvgnd_1
XFILLER_13_335 VGND VGND VPWR VPWR sky130_fd_sc_hd__fill_1
XFILLER_15_63 VGND VGND VPWR VPWR sky130_fd_sc_hd__decap_3
XFILLER_40_154 VGND VGND VPWR VPWR sky130_fd_sc_hd__fill_2
XFILLER_41_688 VGND VGND VPWR VPWR sky130_fd_sc_hd__decap_3
XFILLER_21_390 VGND VGND VPWR VPWR sky130_fd_sc_hd__fill_2
XFILLER_40_187 VGND VGND VPWR VPWR sky130_fd_sc_hd__decap_3
XTAP_TAPCELL_ROW_97_1413 VGND VPWR sky130_fd_sc_hd__tapvpwrvgnd_1
XFILLER_31_40 VGND VGND VPWR VPWR sky130_fd_sc_hd__decap_3
XFILLER_31_84 VGND VGND VPWR VPWR sky130_fd_sc_hd__decap_3
XFILLER_107_495 VGND VGND VPWR VPWR sky130_fd_sc_hd__decap_3
XFILLER_110_616 VGND VGND VPWR VPWR sky130_fd_sc_hd__decap_3
XTAP_TAPCELL_ROW_8_350 VGND VPWR sky130_fd_sc_hd__tapvpwrvgnd_1
XFILLER_95_327 VGND VGND VPWR VPWR sky130_fd_sc_hd__fill_1
XFILLER_48_232 VGND VGND VPWR VPWR sky130_fd_sc_hd__fill_2
XFILLER_95_349 VGND VGND VPWR VPWR sky130_fd_sc_hd__fill_1
XFILLER_48_276 VGND VGND VPWR VPWR sky130_fd_sc_hd__decap_3
XFILLER_17_630 VGND VGND VPWR VPWR sky130_fd_sc_hd__decap_3
XFILLER_56_81 VGND VGND VPWR VPWR sky130_fd_sc_hd__decap_3
Xclkbuf_leaf_28_clk clkbuf_3_2__f_clk/X VGND VGND VPWR VPWR _6946_/CLK sky130_fd_sc_hd__clkbuf_16
XTAP_TAPCELL_ROW_106_1520 VGND VPWR sky130_fd_sc_hd__tapvpwrvgnd_1
XFILLER_17_652 VGND VGND VPWR VPWR sky130_fd_sc_hd__decap_3
XFILLER_51_408 VGND VGND VPWR VPWR sky130_fd_sc_hd__decap_3
XFILLER_63_279 VGND VGND VPWR VPWR sky130_fd_sc_hd__fill_1
XFILLER_44_460 VGND VGND VPWR VPWR sky130_fd_sc_hd__fill_1
Xplace279 _3886_/A2 VGND VGND VPWR VPWR _3906_/A2 sky130_fd_sc_hd__buf_2
Xplace268 _3912_/B1 VGND VGND VPWR VPWR _3925_/B1 sky130_fd_sc_hd__buf_2
X_3860_ _3860_/A0 _3859_/X _3864_/S VGND VGND VPWR VPWR _7386_/D sky130_fd_sc_hd__mux2_2
XFILLER_72_91 VGND VGND VPWR VPWR sky130_fd_sc_hd__decap_3
X_3791_ _3775_/X _3790_/X _3896_/B1 VGND VGND VPWR VPWR _4961_/A sky130_fd_sc_hd__o21a_2
XFILLER_31_187 VGND VGND VPWR VPWR sky130_fd_sc_hd__decap_3
XFILLER_75_3 VGND VGND VPWR VPWR sky130_fd_sc_hd__decap_3
X_7200_ _7390_/CLK _7200_/D _6480_/Y VGND VGND VPWR VPWR _7200_/Q sky130_fd_sc_hd__dfrtp_2
X_4412_ _4788_/B _4412_/B VGND VGND VPWR VPWR _4413_/A sky130_fd_sc_hd__or2_2
X_5392_ _5392_/A0 _4945_/X _5396_/S VGND VGND VPWR VPWR _7137_/D sky130_fd_sc_hd__mux2_2
XFILLER_113_421 VGND VGND VPWR VPWR sky130_fd_sc_hd__decap_3
XFILLER_113_432 VGND VGND VPWR VPWR sky130_fd_sc_hd__decap_3
X_7131_ clkload4/A _7131_/D _6411_/Y VGND VGND VPWR VPWR _7131_/Q sky130_fd_sc_hd__dfrtp_2
X_4343_ _4365_/C _4365_/A _4365_/B VGND VGND VPWR VPWR _4343_/X sky130_fd_sc_hd__and3b_2
XPHY_EDGE_ROW_99_Right_99 VGND VGND VPWR VPWR sky130_fd_sc_hd__decap_3
XFILLER_99_644 VGND VGND VPWR VPWR sky130_fd_sc_hd__decap_3
X_7062_ clkload6/A _7062_/D _6342_/Y VGND VGND VPWR VPWR _7062_/Q sky130_fd_sc_hd__dfrtp_2
X_4274_ _4376_/A _4376_/B _4376_/C _4273_/D VGND VGND VPWR VPWR _4274_/Y sky130_fd_sc_hd__o31ai_2
XFILLER_99_688 VGND VGND VPWR VPWR sky130_fd_sc_hd__decap_3
XFILLER_100_104 VGND VGND VPWR VPWR sky130_fd_sc_hd__decap_3
XFILLER_101_638 VGND VGND VPWR VPWR sky130_fd_sc_hd__decap_3
XFILLER_39_221 VGND VGND VPWR VPWR sky130_fd_sc_hd__decap_3
XFILLER_79_390 VGND VGND VPWR VPWR sky130_fd_sc_hd__fill_2
XFILLER_86_349 VGND VGND VPWR VPWR sky130_fd_sc_hd__decap_3
XFILLER_36_18 VGND VGND VPWR VPWR sky130_fd_sc_hd__decap_3
XFILLER_94_371 VGND VGND VPWR VPWR sky130_fd_sc_hd__fill_2
XFILLER_27_449 VGND VGND VPWR VPWR sky130_fd_sc_hd__fill_1
XFILLER_36_29 VGND VGND VPWR VPWR sky130_fd_sc_hd__fill_1
XFILLER_39_287 VGND VGND VPWR VPWR sky130_fd_sc_hd__decap_3
XFILLER_54_224 VGND VGND VPWR VPWR sky130_fd_sc_hd__decap_3
Xclkbuf_leaf_19_clk clkbuf_3_6__f_clk/X VGND VGND VPWR VPWR _7405_/CLK sky130_fd_sc_hd__clkbuf_16
XPHY_EDGE_ROW_6_Left_123 VGND VGND VPWR VPWR sky130_fd_sc_hd__decap_3
XFILLER_42_419 VGND VGND VPWR VPWR sky130_fd_sc_hd__fill_1
XFILLER_54_268 VGND VGND VPWR VPWR sky130_fd_sc_hd__fill_1
XFILLER_82_577 VGND VGND VPWR VPWR sky130_fd_sc_hd__fill_2
X_6915_ _7383_/CLK _6915_/D VGND VGND VPWR VPWR _6915_/Q sky130_fd_sc_hd__dfxtp_2
XTAP_TAPCELL_ROW_68_1069 VGND VPWR sky130_fd_sc_hd__tapvpwrvgnd_1
XTAP_TAPCELL_ROW_81_1225 VGND VPWR sky130_fd_sc_hd__tapvpwrvgnd_1
XFILLER_52_17 VGND VGND VPWR VPWR sky130_fd_sc_hd__decap_3
X_6846_ _6946_/CLK _6846_/D VGND VGND VPWR VPWR _6846_/Q sky130_fd_sc_hd__dfxtp_2
XFILLER_50_463 VGND VGND VPWR VPWR sky130_fd_sc_hd__decap_3
X_6777_ _7386_/CLK _6777_/D VGND VGND VPWR VPWR _6777_/Q sky130_fd_sc_hd__dfxtp_2
XTAP_TAPCELL_ROW_61_981 VGND VPWR sky130_fd_sc_hd__tapvpwrvgnd_1
XTAP_TAPCELL_ROW_33_650 VGND VPWR sky130_fd_sc_hd__tapvpwrvgnd_1
XFILLER_10_327 VGND VGND VPWR VPWR sky130_fd_sc_hd__decap_3
X_3989_ _7346_/Q _4530_/A0 _3989_/S VGND VGND VPWR VPWR _7346_/D sky130_fd_sc_hd__mux2_2
XFILLER_108_215 VGND VGND VPWR VPWR sky130_fd_sc_hd__decap_3
XFILLER_6_309 VGND VGND VPWR VPWR sky130_fd_sc_hd__fill_2
XFILLER_108_248 VGND VGND VPWR VPWR sky130_fd_sc_hd__decap_3
X_5659_ _5659_/A _5659_/B VGND VGND VPWR VPWR _5660_/D sky130_fd_sc_hd__nor2_2
XTAP_TAPCELL_ROW_79_1198 VGND VPWR sky130_fd_sc_hd__tapvpwrvgnd_1
XFILLER_104_421 VGND VGND VPWR VPWR sky130_fd_sc_hd__decap_3
XFILLER_116_292 VGND VGND VPWR VPWR sky130_fd_sc_hd__decap_3
XFILLER_7_6 VGND VGND VPWR VPWR sky130_fd_sc_hd__decap_3
X_7329_ _7334_/CLK _7329_/D _6609_/Y VGND VGND VPWR VPWR _7329_/Q sky130_fd_sc_hd__dfrtp_2
XTAP_TAPCELL_ROW_92_1354 VGND VPWR sky130_fd_sc_hd__tapvpwrvgnd_1
XFILLER_89_132 VGND VGND VPWR VPWR sky130_fd_sc_hd__fill_1
XFILLER_89_143 VGND VGND VPWR VPWR sky130_fd_sc_hd__decap_3
XFILLER_100_660 VGND VGND VPWR VPWR sky130_fd_sc_hd__decap_3
XFILLER_73_500 VGND VGND VPWR VPWR sky130_fd_sc_hd__decap_3
Xhold1050 _7254_/Q VGND VGND VPWR VPWR _5122_/A0 sky130_fd_sc_hd__dlygate4sd3_1
XFILLER_93_57 VGND VGND VPWR VPWR sky130_fd_sc_hd__decap_3
Xhold1061 _7236_/Q VGND VGND VPWR VPWR _5184_/A sky130_fd_sc_hd__dlygate4sd3_1
Xhold1072 _7242_/Q VGND VGND VPWR VPWR _5171_/A sky130_fd_sc_hd__dlygate4sd3_1
Xhold1083 _7264_/Q VGND VGND VPWR VPWR _4965_/A0 sky130_fd_sc_hd__dlygate4sd3_1
Xhold1094 _7342_/Q VGND VGND VPWR VPWR _4474_/A0 sky130_fd_sc_hd__dlygate4sd3_1
XFILLER_26_51 VGND VGND VPWR VPWR sky130_fd_sc_hd__decap_3
XFILLER_45_246 VGND VGND VPWR VPWR sky130_fd_sc_hd__decap_3
XFILLER_93_79 VGND VGND VPWR VPWR sky130_fd_sc_hd__decap_3
XFILLER_60_205 VGND VGND VPWR VPWR sky130_fd_sc_hd__decap_3
XFILLER_60_227 VGND VGND VPWR VPWR sky130_fd_sc_hd__decap_3
XFILLER_41_430 VGND VGND VPWR VPWR sky130_fd_sc_hd__fill_1
XFILLER_53_290 VGND VGND VPWR VPWR sky130_fd_sc_hd__decap_3
XFILLER_60_249 VGND VGND VPWR VPWR sky130_fd_sc_hd__decap_3
XFILLER_9_125 VGND VGND VPWR VPWR sky130_fd_sc_hd__fill_1
XFILLER_13_187 VGND VGND VPWR VPWR sky130_fd_sc_hd__decap_3
XTAP_TAPCELL_ROW_101_1461 VGND VPWR sky130_fd_sc_hd__tapvpwrvgnd_1
XFILLER_42_83 VGND VGND VPWR VPWR sky130_fd_sc_hd__fill_1
XFILLER_42_94 VGND VGND VPWR VPWR sky130_fd_sc_hd__fill_1
XFILLER_61_9 VGND VGND VPWR VPWR sky130_fd_sc_hd__decap_3
XTAP_TAPCELL_ROW_11_388 VGND VPWR sky130_fd_sc_hd__tapvpwrvgnd_1
XFILLER_114_218 VGND VGND VPWR VPWR sky130_fd_sc_hd__decap_3
XFILLER_107_270 VGND VGND VPWR VPWR sky130_fd_sc_hd__decap_3
XFILLER_107_281 VGND VGND VPWR VPWR sky130_fd_sc_hd__decap_3
XFILLER_5_375 VGND VGND VPWR VPWR sky130_fd_sc_hd__decap_3
XFILLER_110_413 VGND VGND VPWR VPWR sky130_fd_sc_hd__fill_1
XFILLER_1_570 VGND VGND VPWR VPWR sky130_fd_sc_hd__decap_3
XFILLER_3_33 VGND VGND VPWR VPWR sky130_fd_sc_hd__decap_3
XFILLER_95_113 VGND VGND VPWR VPWR sky130_fd_sc_hd__decap_3
XFILLER_96_614 VGND VGND VPWR VPWR sky130_fd_sc_hd__decap_3
XFILLER_3_66 VGND VGND VPWR VPWR sky130_fd_sc_hd__decap_3
XFILLER_68_349 VGND VGND VPWR VPWR sky130_fd_sc_hd__decap_3
XFILLER_95_135 VGND VGND VPWR VPWR sky130_fd_sc_hd__decap_3
XFILLER_96_669 VGND VGND VPWR VPWR sky130_fd_sc_hd__decap_3
XTAP_TAPCELL_ROW_112_1590 VGND VPWR sky130_fd_sc_hd__tapvpwrvgnd_1
XPHY_EDGE_ROW_79_Left_196 VGND VGND VPWR VPWR sky130_fd_sc_hd__decap_3
XFILLER_3_99 VGND VGND VPWR VPWR sky130_fd_sc_hd__decap_3
XFILLER_36_224 VGND VGND VPWR VPWR sky130_fd_sc_hd__decap_3
XFILLER_64_533 VGND VGND VPWR VPWR sky130_fd_sc_hd__decap_3
XFILLER_24_419 VGND VGND VPWR VPWR sky130_fd_sc_hd__fill_1
XFILLER_91_374 VGND VGND VPWR VPWR sky130_fd_sc_hd__decap_3
XFILLER_91_385 VGND VGND VPWR VPWR sky130_fd_sc_hd__decap_3
XFILLER_91_396 VGND VGND VPWR VPWR sky130_fd_sc_hd__fill_2
X_4961_ _4961_/A _5662_/C _4961_/C VGND VGND VPWR VPWR _4961_/X sky130_fd_sc_hd__or3_4
XTAP_TAPCELL_ROW_19_477 VGND VPWR sky130_fd_sc_hd__tapvpwrvgnd_1
XFILLER_17_493 VGND VGND VPWR VPWR sky130_fd_sc_hd__decap_3
XFILLER_32_441 VGND VGND VPWR VPWR sky130_fd_sc_hd__decap_3
XFILLER_51_249 VGND VGND VPWR VPWR sky130_fd_sc_hd__fill_1
X_6700_ _7386_/CLK _6700_/D VGND VGND VPWR VPWR _6700_/Q sky130_fd_sc_hd__dfxtp_2
X_4892_ _4884_/X _4886_/X _4887_/Y _4891_/X VGND VGND VPWR VPWR _5656_/B sky130_fd_sc_hd__a31o_2
X_3912_ _6905_/Q _3926_/A2 _3912_/B1 _6897_/Q VGND VGND VPWR VPWR _3912_/X sky130_fd_sc_hd__a22o_2
X_6631_ _6635_/A VGND VGND VPWR VPWR _6631_/Y sky130_fd_sc_hd__inv_2
X_3843_ _6699_/Q _3656_/Y _3917_/B1 _6877_/Q _3842_/X VGND VGND VPWR VPWR _3843_/X
+ sky130_fd_sc_hd__a221o_2
X_6562_ _6562_/A VGND VGND VPWR VPWR _6562_/Y sky130_fd_sc_hd__inv_2
X_3774_ _6757_/Q _3913_/B1 _3883_/B1 _6769_/Q _3773_/X VGND VGND VPWR VPWR _3774_/X
+ sky130_fd_sc_hd__a221o_2
X_6493_ _6651_/A VGND VGND VPWR VPWR _6493_/Y sky130_fd_sc_hd__inv_2
Xclkbuf_leaf_8_clk clkbuf_leaf_9_clk/A VGND VGND VPWR VPWR _7334_/CLK sky130_fd_sc_hd__clkbuf_16
XFILLER_99_430 VGND VGND VPWR VPWR sky130_fd_sc_hd__decap_3
XFILLER_113_240 VGND VGND VPWR VPWR sky130_fd_sc_hd__decap_3
X_7114_ _7402_/CLK _7114_/D _6394_/Y VGND VGND VPWR VPWR _7114_/Q sky130_fd_sc_hd__dfrtp_2
Xoutput477 _5663_/C VGND VGND VPWR VPWR alu_result_out[22] sky130_fd_sc_hd__clkdlybuf4s25_1
Xoutput466 _5658_/B VGND VGND VPWR VPWR alu_result_out[12] sky130_fd_sc_hd__clkdlybuf4s25_1
X_5375_ _5375_/A0 _4806_/X _5386_/S VGND VGND VPWR VPWR _7145_/D sky130_fd_sc_hd__mux2_2
XFILLER_99_452 VGND VGND VPWR VPWR sky130_fd_sc_hd__decap_3
XFILLER_101_413 VGND VGND VPWR VPWR sky130_fd_sc_hd__fill_2
XFILLER_113_273 VGND VGND VPWR VPWR sky130_fd_sc_hd__decap_3
XFILLER_59_327 VGND VGND VPWR VPWR sky130_fd_sc_hd__decap_3
Xoutput499 _3525_/B VGND VGND VPWR VPWR instruction_out[14] sky130_fd_sc_hd__clkdlybuf4s25_1
Xoutput488 _3640_/X VGND VGND VPWR VPWR alu_result_out[3] sky130_fd_sc_hd__clkdlybuf4s25_1
X_4326_ _7013_/Q _4341_/A2 _4322_/X _4325_/X VGND VGND VPWR VPWR _4327_/B sky130_fd_sc_hd__a211o_2
XFILLER_101_435 VGND VGND VPWR VPWR sky130_fd_sc_hd__decap_3
XFILLER_59_349 VGND VGND VPWR VPWR sky130_fd_sc_hd__decap_3
XFILLER_87_647 VGND VGND VPWR VPWR sky130_fd_sc_hd__decap_3
X_7045_ _7390_/CLK _7045_/D _6325_/Y VGND VGND VPWR VPWR _7045_/Q sky130_fd_sc_hd__dfrtp_2
X_4257_ _4626_/B _4626_/C _4256_/C VGND VGND VPWR VPWR _4988_/B sky130_fd_sc_hd__a21oi_2
XFILLER_86_157 VGND VGND VPWR VPWR sky130_fd_sc_hd__decap_3
X_4188_ _7359_/Q _4196_/A2 _4187_/X _4248_/A VGND VGND VPWR VPWR _4188_/X sky130_fd_sc_hd__a211o_2
XFILLER_103_12 VGND VGND VPWR VPWR sky130_fd_sc_hd__decap_3
XFILLER_95_691 VGND VGND VPWR VPWR sky130_fd_sc_hd__fill_1
XFILLER_27_246 VGND VGND VPWR VPWR sky130_fd_sc_hd__decap_3
XFILLER_103_78 VGND VGND VPWR VPWR sky130_fd_sc_hd__decap_3
XFILLER_27_279 VGND VGND VPWR VPWR sky130_fd_sc_hd__fill_1
XFILLER_42_216 VGND VGND VPWR VPWR sky130_fd_sc_hd__decap_3
XFILLER_55_588 VGND VGND VPWR VPWR sky130_fd_sc_hd__decap_3
XFILLER_70_536 VGND VGND VPWR VPWR sky130_fd_sc_hd__decap_3
XFILLER_82_396 VGND VGND VPWR VPWR sky130_fd_sc_hd__decap_3
XFILLER_42_249 VGND VGND VPWR VPWR sky130_fd_sc_hd__decap_3
XFILLER_23_452 VGND VGND VPWR VPWR sky130_fd_sc_hd__decap_3
X_6829_ _6946_/CLK _6829_/D VGND VGND VPWR VPWR _6829_/Q sky130_fd_sc_hd__dfxtp_2
XFILLER_10_124 VGND VGND VPWR VPWR sky130_fd_sc_hd__decap_3
XFILLER_50_271 VGND VGND VPWR VPWR sky130_fd_sc_hd__decap_3
XFILLER_7_607 VGND VGND VPWR VPWR sky130_fd_sc_hd__decap_3
XFILLER_6_106 VGND VGND VPWR VPWR sky130_fd_sc_hd__decap_3
XFILLER_12_53 VGND VGND VPWR VPWR sky130_fd_sc_hd__decap_3
XFILLER_6_139 VGND VGND VPWR VPWR sky130_fd_sc_hd__fill_1
XFILLER_109_579 VGND VGND VPWR VPWR sky130_fd_sc_hd__decap_3
XFILLER_88_24 VGND VGND VPWR VPWR sky130_fd_sc_hd__decap_3
XFILLER_2_356 VGND VGND VPWR VPWR sky130_fd_sc_hd__fill_2
XFILLER_5_3 VGND VGND VPWR VPWR sky130_fd_sc_hd__decap_3
XFILLER_88_57 VGND VGND VPWR VPWR sky130_fd_sc_hd__decap_3
XFILLER_104_262 VGND VGND VPWR VPWR sky130_fd_sc_hd__decap_3
XFILLER_2_389 VGND VGND VPWR VPWR sky130_fd_sc_hd__decap_3
XFILLER_77_135 VGND VGND VPWR VPWR sky130_fd_sc_hd__decap_3
XFILLER_78_669 VGND VGND VPWR VPWR sky130_fd_sc_hd__decap_3
XFILLER_65_319 VGND VGND VPWR VPWR sky130_fd_sc_hd__decap_3
XFILLER_93_617 VGND VGND VPWR VPWR sky130_fd_sc_hd__decap_3
XFILLER_58_371 VGND VGND VPWR VPWR sky130_fd_sc_hd__decap_3
XFILLER_92_127 VGND VGND VPWR VPWR sky130_fd_sc_hd__decap_3
XFILLER_18_279 VGND VGND VPWR VPWR sky130_fd_sc_hd__decap_3
XFILLER_33_205 VGND VGND VPWR VPWR sky130_fd_sc_hd__fill_1
XFILLER_73_385 VGND VGND VPWR VPWR sky130_fd_sc_hd__decap_3
XFILLER_73_396 VGND VGND VPWR VPWR sky130_fd_sc_hd__fill_1
XTAP_TAPCELL_ROW_16_447 VGND VPWR sky130_fd_sc_hd__tapvpwrvgnd_1
XTAP_TAPCELL_ROW_44_778 VGND VPWR sky130_fd_sc_hd__tapvpwrvgnd_1
XFILLER_41_293 VGND VGND VPWR VPWR sky130_fd_sc_hd__decap_3
XFILLER_10_680 VGND VGND VPWR VPWR sky130_fd_sc_hd__decap_3
XFILLER_115_505 VGND VGND VPWR VPWR sky130_fd_sc_hd__decap_3
X_3490_ _7119_/Q _4348_/B1 _3489_/X _4347_/C1 VGND VGND VPWR VPWR _3490_/X sky130_fd_sc_hd__a211o_2
XFILLER_115_538 VGND VGND VPWR VPWR sky130_fd_sc_hd__decap_3
XFILLER_5_161 VGND VGND VPWR VPWR sky130_fd_sc_hd__decap_3
XFILLER_6_673 VGND VGND VPWR VPWR sky130_fd_sc_hd__decap_3
XFILLER_38_3 VGND VGND VPWR VPWR sky130_fd_sc_hd__decap_3
XPHY_EDGE_ROW_87_Left_204 VGND VGND VPWR VPWR sky130_fd_sc_hd__decap_3
XFILLER_68_124 VGND VGND VPWR VPWR sky130_fd_sc_hd__decap_3
XFILLER_69_647 VGND VGND VPWR VPWR sky130_fd_sc_hd__decap_3
X_5091_ _6985_/Q _5068_/C _6986_/Q VGND VGND VPWR VPWR _5092_/B sky130_fd_sc_hd__a21o_2
X_4111_ _4109_/X _4111_/B VGND VGND VPWR VPWR _4845_/A sky130_fd_sc_hd__nand2b_2
XFILLER_84_628 VGND VGND VPWR VPWR sky130_fd_sc_hd__decap_3
XFILLER_96_477 VGND VGND VPWR VPWR sky130_fd_sc_hd__decap_3
X_4042_ _7341_/Q _3935_/S _4437_/B1 _7373_/Q _4429_/C1 VGND VGND VPWR VPWR _4042_/X
+ sky130_fd_sc_hd__a221o_2
XFILLER_110_298 VGND VGND VPWR VPWR sky130_fd_sc_hd__fill_1
XFILLER_49_393 VGND VGND VPWR VPWR sky130_fd_sc_hd__decap_3
XFILLER_77_691 VGND VGND VPWR VPWR sky130_fd_sc_hd__fill_1
XFILLER_83_116 VGND VGND VPWR VPWR sky130_fd_sc_hd__decap_3
XFILLER_83_149 VGND VGND VPWR VPWR sky130_fd_sc_hd__decap_3
XFILLER_24_227 VGND VGND VPWR VPWR sky130_fd_sc_hd__decap_3
XFILLER_37_577 VGND VGND VPWR VPWR sky130_fd_sc_hd__fill_1
XFILLER_64_385 VGND VGND VPWR VPWR sky130_fd_sc_hd__decap_3
XFILLER_92_672 VGND VGND VPWR VPWR sky130_fd_sc_hd__decap_3
XTAP_TAPCELL_ROW_65_1028 VGND VPWR sky130_fd_sc_hd__tapvpwrvgnd_1
X_4944_ _5010_/A _4944_/B _4944_/C VGND VGND VPWR VPWR _4944_/X sky130_fd_sc_hd__or3_2
XPHY_EDGE_ROW_96_Left_213 VGND VGND VPWR VPWR sky130_fd_sc_hd__decap_3
XFILLER_20_433 VGND VGND VPWR VPWR sky130_fd_sc_hd__decap_3
XFILLER_32_271 VGND VGND VPWR VPWR sky130_fd_sc_hd__decap_3
X_4875_ _4842_/X _4871_/Y _4874_/X VGND VGND VPWR VPWR _5663_/C sky130_fd_sc_hd__a21bo_2
X_6614_ _6616_/A VGND VGND VPWR VPWR _6614_/Y sky130_fd_sc_hd__inv_2
X_3826_ _6731_/Q _3913_/B1 _3912_/B1 _6743_/Q _3825_/X VGND VGND VPWR VPWR _3826_/X
+ sky130_fd_sc_hd__a221o_2
X_6545_ _6578_/A VGND VGND VPWR VPWR _6545_/Y sky130_fd_sc_hd__inv_2
X_3757_ _3757_/A0 _3756_/X _3757_/S VGND VGND VPWR VPWR _7396_/D sky130_fd_sc_hd__mux2_2
XFILLER_106_505 VGND VGND VPWR VPWR sky130_fd_sc_hd__fill_2
XFILLER_106_527 VGND VGND VPWR VPWR sky130_fd_sc_hd__decap_3
XFILLER_109_9 VGND VGND VPWR VPWR sky130_fd_sc_hd__decap_3
X_6476_ _6644_/A VGND VGND VPWR VPWR _6476_/Y sky130_fd_sc_hd__inv_2
X_5427_ _5427_/A0 _5156_/X _5429_/S VGND VGND VPWR VPWR _7120_/D sky130_fd_sc_hd__mux2_2
XTAP_TAPCELL_ROW_76_1168 VGND VPWR sky130_fd_sc_hd__tapvpwrvgnd_1
XFILLER_114_560 VGND VGND VPWR VPWR sky130_fd_sc_hd__decap_3
XFILLER_58_27 VGND VGND VPWR VPWR sky130_fd_sc_hd__fill_1
XFILLER_58_38 VGND VGND VPWR VPWR sky130_fd_sc_hd__decap_3
XFILLER_59_102 VGND VGND VPWR VPWR sky130_fd_sc_hd__decap_3
X_5358_ _5358_/A0 _5156_/X _5358_/S VGND VGND VPWR VPWR _7152_/D sky130_fd_sc_hd__mux2_2
XFILLER_59_113 VGND VGND VPWR VPWR sky130_fd_sc_hd__decap_3
XFILLER_59_146 VGND VGND VPWR VPWR sky130_fd_sc_hd__decap_3
XFILLER_87_455 VGND VGND VPWR VPWR sky130_fd_sc_hd__decap_3
X_4309_ _7128_/Q _3407_/X _4307_/X _4308_/X VGND VGND VPWR VPWR _4311_/B sky130_fd_sc_hd__a211o_2
XFILLER_99_293 VGND VGND VPWR VPWR sky130_fd_sc_hd__decap_3
XFILLER_47_308 VGND VGND VPWR VPWR sky130_fd_sc_hd__decap_3
XFILLER_75_617 VGND VGND VPWR VPWR sky130_fd_sc_hd__decap_3
X_7028_ _7387_/CLK _7028_/D _6308_/Y VGND VGND VPWR VPWR _7028_/Q sky130_fd_sc_hd__dfrtp_2
XFILLER_101_276 VGND VGND VPWR VPWR sky130_fd_sc_hd__decap_3
XFILLER_114_44 VGND VGND VPWR VPWR sky130_fd_sc_hd__decap_3
XFILLER_28_533 VGND VGND VPWR VPWR sky130_fd_sc_hd__decap_3
XFILLER_75_639 VGND VGND VPWR VPWR sky130_fd_sc_hd__decap_3
XFILLER_114_77 VGND VGND VPWR VPWR sky130_fd_sc_hd__decap_3
XFILLER_114_88 VGND VGND VPWR VPWR sky130_fd_sc_hd__decap_3
XFILLER_55_330 VGND VGND VPWR VPWR sky130_fd_sc_hd__decap_3
XFILLER_74_48 VGND VGND VPWR VPWR sky130_fd_sc_hd__decap_3
XFILLER_83_650 VGND VGND VPWR VPWR sky130_fd_sc_hd__decap_3
XFILLER_43_503 VGND VGND VPWR VPWR sky130_fd_sc_hd__fill_1
XFILLER_55_363 VGND VGND VPWR VPWR sky130_fd_sc_hd__decap_3
XTAP_TAPCELL_ROW_87_1297 VGND VPWR sky130_fd_sc_hd__tapvpwrvgnd_1
XFILLER_30_208 VGND VGND VPWR VPWR sky130_fd_sc_hd__fill_2
XFILLER_70_377 VGND VGND VPWR VPWR sky130_fd_sc_hd__decap_3
XFILLER_90_14 VGND VGND VPWR VPWR sky130_fd_sc_hd__decap_3
XTAP_TAPCELL_ROW_13_406 VGND VPWR sky130_fd_sc_hd__tapvpwrvgnd_1
XFILLER_23_30 VGND VGND VPWR VPWR sky130_fd_sc_hd__decap_3
XFILLER_90_58 VGND VGND VPWR VPWR sky130_fd_sc_hd__decap_3
XTAP_TAPCELL_ROW_41_748 VGND VPWR sky130_fd_sc_hd__tapvpwrvgnd_1
XFILLER_23_63 VGND VGND VPWR VPWR sky130_fd_sc_hd__decap_3
XFILLER_11_477 VGND VGND VPWR VPWR sky130_fd_sc_hd__fill_2
XFILLER_11_499 VGND VGND VPWR VPWR sky130_fd_sc_hd__decap_3
XFILLER_23_96 VGND VGND VPWR VPWR sky130_fd_sc_hd__decap_3
XFILLER_7_437 VGND VGND VPWR VPWR sky130_fd_sc_hd__decap_3
XFILLER_109_387 VGND VGND VPWR VPWR sky130_fd_sc_hd__decap_3
XFILLER_99_78 VGND VGND VPWR VPWR sky130_fd_sc_hd__decap_3
XFILLER_3_643 VGND VGND VPWR VPWR sky130_fd_sc_hd__decap_3
XFILLER_2_153 VGND VGND VPWR VPWR sky130_fd_sc_hd__decap_3
XFILLER_3_676 VGND VGND VPWR VPWR sky130_fd_sc_hd__decap_3
XFILLER_97_208 VGND VGND VPWR VPWR sky130_fd_sc_hd__decap_3
XFILLER_65_105 VGND VGND VPWR VPWR sky130_fd_sc_hd__decap_3
XFILLER_66_628 VGND VGND VPWR VPWR sky130_fd_sc_hd__decap_3
XFILLER_93_403 VGND VGND VPWR VPWR sky130_fd_sc_hd__decap_3
XFILLER_59_691 VGND VGND VPWR VPWR sky130_fd_sc_hd__fill_1
XFILLER_65_116 VGND VGND VPWR VPWR sky130_fd_sc_hd__decap_3
XTAP_TAPCELL_ROW_49_837 VGND VPWR sky130_fd_sc_hd__tapvpwrvgnd_1
XFILLER_46_374 VGND VGND VPWR VPWR sky130_fd_sc_hd__decap_3
XFILLER_46_385 VGND VGND VPWR VPWR sky130_fd_sc_hd__decap_3
XFILLER_73_160 VGND VGND VPWR VPWR sky130_fd_sc_hd__decap_3
XFILLER_74_672 VGND VGND VPWR VPWR sky130_fd_sc_hd__decap_3
XFILLER_0_89 VGND VGND VPWR VPWR sky130_fd_sc_hd__decap_3
XFILLER_61_322 VGND VGND VPWR VPWR sky130_fd_sc_hd__decap_3
XFILLER_73_182 VGND VGND VPWR VPWR sky130_fd_sc_hd__decap_3
XTAP_TAPCELL_ROW_29_594 VGND VPWR sky130_fd_sc_hd__tapvpwrvgnd_1
XFILLER_21_208 VGND VGND VPWR VPWR sky130_fd_sc_hd__fill_1
XFILLER_61_355 VGND VGND VPWR VPWR sky130_fd_sc_hd__decap_3
XFILLER_9_21 VGND VGND VPWR VPWR sky130_fd_sc_hd__decap_3
XFILLER_14_271 VGND VGND VPWR VPWR sky130_fd_sc_hd__fill_1
XFILLER_61_399 VGND VGND VPWR VPWR sky130_fd_sc_hd__decap_3
XFILLER_9_54 VGND VGND VPWR VPWR sky130_fd_sc_hd__fill_2
X_4660_ _4720_/A _4655_/X _4658_/A VGND VGND VPWR VPWR _4660_/X sky130_fd_sc_hd__a21bo_2
XFILLER_9_87 VGND VGND VPWR VPWR sky130_fd_sc_hd__decap_3
XFILLER_80_80 VGND VGND VPWR VPWR sky130_fd_sc_hd__decap_3
X_3611_ _5057_/A _3611_/B VGND VGND VPWR VPWR _3611_/Y sky130_fd_sc_hd__nor2_2
X_6330_ _6682_/A VGND VGND VPWR VPWR _6330_/Y sky130_fd_sc_hd__inv_2
X_4591_ _7285_/Q _4595_/B VGND VGND VPWR VPWR _7285_/D sky130_fd_sc_hd__and2_2
Xhold905 _7088_/Q VGND VGND VPWR VPWR _7088_/D sky130_fd_sc_hd__dlygate4sd3_1
Xhold916 _6712_/Q VGND VGND VPWR VPWR hold916/X sky130_fd_sc_hd__dlygate4sd3_1
Xhold927 _7023_/Q VGND VGND VPWR VPWR _5609_/A sky130_fd_sc_hd__dlygate4sd3_1
XFILLER_103_508 VGND VGND VPWR VPWR sky130_fd_sc_hd__fill_1
XFILLER_115_346 VGND VGND VPWR VPWR sky130_fd_sc_hd__decap_3
Xhold938 _7032_/Q VGND VGND VPWR VPWR _5591_/A sky130_fd_sc_hd__dlygate4sd3_1
Xhold949 _7043_/Q VGND VGND VPWR VPWR hold949/X sky130_fd_sc_hd__dlygate4sd3_1
X_6261_ _6385_/A VGND VGND VPWR VPWR _6261_/Y sky130_fd_sc_hd__inv_2
X_3473_ _7312_/Q _3989_/S _4332_/B1 _7344_/Q _4347_/C1 VGND VGND VPWR VPWR _3473_/X
+ sky130_fd_sc_hd__a221o_2
XFILLER_69_433 VGND VGND VPWR VPWR sky130_fd_sc_hd__decap_3
XFILLER_29_319 VGND VGND VPWR VPWR sky130_fd_sc_hd__decap_3
XFILLER_57_606 VGND VGND VPWR VPWR sky130_fd_sc_hd__decap_3
XFILLER_57_617 VGND VGND VPWR VPWR sky130_fd_sc_hd__decap_3
XFILLER_111_585 VGND VGND VPWR VPWR sky130_fd_sc_hd__decap_3
X_5074_ _4852_/A _5073_/A _5073_/Y _5146_/B1 VGND VGND VPWR VPWR _5075_/C sky130_fd_sc_hd__a2bb2o_2
XTAP_TAPCELL_ROW_71_1098 VGND VPWR sky130_fd_sc_hd__tapvpwrvgnd_1
XFILLER_56_149 VGND VGND VPWR VPWR sky130_fd_sc_hd__decap_3
XFILLER_65_650 VGND VGND VPWR VPWR sky130_fd_sc_hd__decap_3
XFILLER_71_119 VGND VGND VPWR VPWR sky130_fd_sc_hd__fill_2
XFILLER_37_396 VGND VGND VPWR VPWR sky130_fd_sc_hd__fill_2
XFILLER_44_18 VGND VGND VPWR VPWR sky130_fd_sc_hd__decap_3
XFILLER_52_333 VGND VGND VPWR VPWR sky130_fd_sc_hd__decap_3
XFILLER_64_171 VGND VGND VPWR VPWR sky130_fd_sc_hd__decap_3
XFILLER_80_642 VGND VGND VPWR VPWR sky130_fd_sc_hd__fill_2
XFILLER_92_480 VGND VGND VPWR VPWR sky130_fd_sc_hd__decap_3
XFILLER_40_517 VGND VGND VPWR VPWR sky130_fd_sc_hd__decap_3
XFILLER_80_675 VGND VGND VPWR VPWR sky130_fd_sc_hd__decap_3
XFILLER_100_46 VGND VGND VPWR VPWR sky130_fd_sc_hd__decap_3
XFILLER_40_539 VGND VGND VPWR VPWR sky130_fd_sc_hd__decap_3
X_4927_ _5581_/S _4927_/B _5656_/C VGND VGND VPWR VPWR _4927_/X sky130_fd_sc_hd__or3_2
X_4858_ _6999_/Q _4858_/B VGND VGND VPWR VPWR _4870_/A sky130_fd_sc_hd__and2_2
XFILLER_60_39 VGND VGND VPWR VPWR sky130_fd_sc_hd__decap_3
X_3809_ _6836_/Q _3913_/A2 _3665_/X _6841_/Q VGND VGND VPWR VPWR _3809_/X sky130_fd_sc_hd__a22o_2
X_4789_ _5057_/A _4412_/B _4413_/A _4852_/A _4788_/Y VGND VGND VPWR VPWR _4789_/X
+ sky130_fd_sc_hd__o221a_2
XFILLER_109_33 VGND VGND VPWR VPWR sky130_fd_sc_hd__decap_3
XFILLER_4_418 VGND VGND VPWR VPWR sky130_fd_sc_hd__fill_2
X_6528_ _6640_/A VGND VGND VPWR VPWR _6528_/Y sky130_fd_sc_hd__inv_2
XFILLER_109_66 VGND VGND VPWR VPWR sky130_fd_sc_hd__decap_3
XFILLER_109_99 VGND VGND VPWR VPWR sky130_fd_sc_hd__decap_3
XFILLER_69_15 VGND VGND VPWR VPWR sky130_fd_sc_hd__decap_3
X_6459_ _6558_/A VGND VGND VPWR VPWR _6459_/Y sky130_fd_sc_hd__inv_2
XFILLER_106_368 VGND VGND VPWR VPWR sky130_fd_sc_hd__decap_3
XFILLER_0_657 VGND VGND VPWR VPWR sky130_fd_sc_hd__decap_3
XFILLER_102_552 VGND VGND VPWR VPWR sky130_fd_sc_hd__decap_3
XFILLER_85_14 VGND VGND VPWR VPWR sky130_fd_sc_hd__decap_3
XFILLER_87_263 VGND VGND VPWR VPWR sky130_fd_sc_hd__decap_3
XFILLER_48_628 VGND VGND VPWR VPWR sky130_fd_sc_hd__decap_3
XFILLER_75_414 VGND VGND VPWR VPWR sky130_fd_sc_hd__decap_3
XTAP_TAPCELL_ROW_89_1315 VGND VPWR sky130_fd_sc_hd__tapvpwrvgnd_1
XFILLER_28_341 VGND VGND VPWR VPWR sky130_fd_sc_hd__decap_3
XTAP_TAPCELL_ROW_46_807 VGND VPWR sky130_fd_sc_hd__tapvpwrvgnd_1
XFILLER_18_85 VGND VGND VPWR VPWR sky130_fd_sc_hd__decap_3
XFILLER_28_352 VGND VGND VPWR VPWR sky130_fd_sc_hd__decap_3
XFILLER_56_683 VGND VGND VPWR VPWR sky130_fd_sc_hd__decap_3
XFILLER_62_119 VGND VGND VPWR VPWR sky130_fd_sc_hd__decap_3
XFILLER_16_547 VGND VGND VPWR VPWR sky130_fd_sc_hd__decap_3
XFILLER_43_311 VGND VGND VPWR VPWR sky130_fd_sc_hd__fill_2
XFILLER_71_653 VGND VGND VPWR VPWR sky130_fd_sc_hd__decap_3
XFILLER_83_480 VGND VGND VPWR VPWR sky130_fd_sc_hd__decap_3
XFILLER_31_517 VGND VGND VPWR VPWR sky130_fd_sc_hd__decap_3
XFILLER_70_130 VGND VGND VPWR VPWR sky130_fd_sc_hd__decap_3
XFILLER_70_141 VGND VGND VPWR VPWR sky130_fd_sc_hd__decap_3
XTAP_TAPCELL_ROW_26_564 VGND VPWR sky130_fd_sc_hd__tapvpwrvgnd_1
XFILLER_34_73 VGND VGND VPWR VPWR sky130_fd_sc_hd__decap_3
XFILLER_70_174 VGND VGND VPWR VPWR sky130_fd_sc_hd__decap_3
XTAP_TAPCELL_ROW_54_895 VGND VPWR sky130_fd_sc_hd__tapvpwrvgnd_1
XFILLER_11_252 VGND VGND VPWR VPWR sky130_fd_sc_hd__decap_3
XFILLER_7_223 VGND VGND VPWR VPWR sky130_fd_sc_hd__fill_1
XFILLER_109_140 VGND VGND VPWR VPWR sky130_fd_sc_hd__decap_3
XFILLER_7_256 VGND VGND VPWR VPWR sky130_fd_sc_hd__decap_3
XFILLER_50_61 VGND VGND VPWR VPWR sky130_fd_sc_hd__decap_3
XFILLER_109_184 VGND VGND VPWR VPWR sky130_fd_sc_hd__decap_3
XFILLER_112_316 VGND VGND VPWR VPWR sky130_fd_sc_hd__fill_1
XFILLER_98_539 VGND VGND VPWR VPWR sky130_fd_sc_hd__decap_3
XFILLER_22_6 VGND VGND VPWR VPWR sky130_fd_sc_hd__decap_3
XFILLER_39_617 VGND VGND VPWR VPWR sky130_fd_sc_hd__decap_3
XFILLER_66_403 VGND VGND VPWR VPWR sky130_fd_sc_hd__decap_3
XFILLER_38_105 VGND VGND VPWR VPWR sky130_fd_sc_hd__decap_3
XFILLER_38_138 VGND VGND VPWR VPWR sky130_fd_sc_hd__fill_2
XFILLER_47_650 VGND VGND VPWR VPWR sky130_fd_sc_hd__decap_3
XFILLER_66_458 VGND VGND VPWR VPWR sky130_fd_sc_hd__decap_3
XFILLER_53_119 VGND VGND VPWR VPWR sky130_fd_sc_hd__decap_3
XFILLER_81_428 VGND VGND VPWR VPWR sky130_fd_sc_hd__fill_1
XTAP_TAPCELL_ROW_109_1562 VGND VPWR sky130_fd_sc_hd__tapvpwrvgnd_1
XFILLER_46_171 VGND VGND VPWR VPWR sky130_fd_sc_hd__fill_1
XFILLER_62_631 VGND VGND VPWR VPWR sky130_fd_sc_hd__decap_3
XFILLER_34_377 VGND VGND VPWR VPWR sky130_fd_sc_hd__decap_3
XFILLER_62_675 VGND VGND VPWR VPWR sky130_fd_sc_hd__decap_3
XFILLER_61_163 VGND VGND VPWR VPWR sky130_fd_sc_hd__decap_3
XFILLER_61_174 VGND VGND VPWR VPWR sky130_fd_sc_hd__decap_3
XFILLER_61_196 VGND VGND VPWR VPWR sky130_fd_sc_hd__fill_1
X_4712_ _7007_/Q _4738_/A VGND VGND VPWR VPWR _4731_/B sky130_fd_sc_hd__nand2_2
X_4643_ _4888_/A _4125_/X _4126_/A VGND VGND VPWR VPWR _4643_/Y sky130_fd_sc_hd__a21oi_2
X_7362_ _7397_/CLK _7362_/D _6642_/Y VGND VGND VPWR VPWR _7362_/Q sky130_fd_sc_hd__dfrtp_2
Xhold702 _6976_/Q VGND VGND VPWR VPWR _6976_/D sky130_fd_sc_hd__dlygate4sd3_1
X_7293_ _7360_/CLK _7293_/D _6573_/Y VGND VGND VPWR VPWR _7293_/Q sky130_fd_sc_hd__dfrtp_2
Xhold713 _6760_/Q VGND VGND VPWR VPWR _6760_/D sky130_fd_sc_hd__dlygate4sd3_1
Xhold724 _6953_/Q VGND VGND VPWR VPWR _6953_/D sky130_fd_sc_hd__dlygate4sd3_1
Xhold735 _6767_/Q VGND VGND VPWR VPWR _6767_/D sky130_fd_sc_hd__dlygate4sd3_1
Xhold746 _6973_/Q VGND VGND VPWR VPWR _6973_/D sky130_fd_sc_hd__dlygate4sd3_1
X_6313_ _6660_/A VGND VGND VPWR VPWR _6313_/Y sky130_fd_sc_hd__inv_2
X_3525_ _3525_/A _3525_/B VGND VGND VPWR VPWR _5072_/A sky130_fd_sc_hd__and2_2
XFILLER_103_305 VGND VGND VPWR VPWR sky130_fd_sc_hd__decap_3
XFILLER_115_143 VGND VGND VPWR VPWR sky130_fd_sc_hd__decap_3
XFILLER_89_539 VGND VGND VPWR VPWR sky130_fd_sc_hd__decap_3
Xhold757 _6955_/Q VGND VGND VPWR VPWR _6955_/D sky130_fd_sc_hd__dlygate4sd3_1
Xhold768 _6972_/Q VGND VGND VPWR VPWR _6972_/D sky130_fd_sc_hd__dlygate4sd3_1
Xhold779 _6832_/Q VGND VGND VPWR VPWR _6832_/D sky130_fd_sc_hd__dlygate4sd3_1
XTAP_TAPCELL_ROW_73_1127 VGND VPWR sky130_fd_sc_hd__tapvpwrvgnd_1
XFILLER_115_187 VGND VGND VPWR VPWR sky130_fd_sc_hd__decap_3
XFILLER_39_18 VGND VGND VPWR VPWR sky130_fd_sc_hd__fill_2
X_3456_ _7011_/Q _4601_/S _3448_/X _3455_/X VGND VGND VPWR VPWR _3456_/X sky130_fd_sc_hd__a211o_2
XFILLER_69_252 VGND VGND VPWR VPWR sky130_fd_sc_hd__decap_3
XFILLER_97_561 VGND VGND VPWR VPWR sky130_fd_sc_hd__decap_3
X_3387_ _3385_/Y _3386_/Y _3977_/S _3399_/B VGND VGND VPWR VPWR _3429_/B sky130_fd_sc_hd__a211o_2
XFILLER_111_382 VGND VGND VPWR VPWR sky130_fd_sc_hd__decap_3
XFILLER_69_263 VGND VGND VPWR VPWR sky130_fd_sc_hd__decap_3
XFILLER_69_296 VGND VGND VPWR VPWR sky130_fd_sc_hd__decap_3
XFILLER_84_200 VGND VGND VPWR VPWR sky130_fd_sc_hd__fill_1
X_5126_ _5126_/A0 _5125_/Y _5136_/S VGND VGND VPWR VPWR _7253_/D sky130_fd_sc_hd__mux2_2
X_5057_ _5057_/A _5057_/B VGND VGND VPWR VPWR _5057_/Y sky130_fd_sc_hd__nor2_2
XFILLER_37_160 VGND VGND VPWR VPWR sky130_fd_sc_hd__decap_3
XFILLER_38_672 VGND VGND VPWR VPWR sky130_fd_sc_hd__decap_3
XFILLER_55_39 VGND VGND VPWR VPWR sky130_fd_sc_hd__decap_3
XFILLER_72_417 VGND VGND VPWR VPWR sky130_fd_sc_hd__decap_3
XFILLER_111_12 VGND VGND VPWR VPWR sky130_fd_sc_hd__decap_3
XFILLER_25_322 VGND VGND VPWR VPWR sky130_fd_sc_hd__decap_3
XFILLER_53_620 VGND VGND VPWR VPWR sky130_fd_sc_hd__decap_3
XFILLER_65_480 VGND VGND VPWR VPWR sky130_fd_sc_hd__decap_3
XFILLER_111_23 VGND VGND VPWR VPWR sky130_fd_sc_hd__decap_3
XFILLER_25_355 VGND VGND VPWR VPWR sky130_fd_sc_hd__fill_1
XFILLER_52_141 VGND VGND VPWR VPWR sky130_fd_sc_hd__decap_3
XFILLER_53_653 VGND VGND VPWR VPWR sky130_fd_sc_hd__decap_3
XTAP_TAPCELL_ROW_84_1256 VGND VPWR sky130_fd_sc_hd__tapvpwrvgnd_1
XFILLER_111_78 VGND VGND VPWR VPWR sky130_fd_sc_hd__decap_3
XFILLER_25_377 VGND VGND VPWR VPWR sky130_fd_sc_hd__decap_3
XFILLER_25_399 VGND VGND VPWR VPWR sky130_fd_sc_hd__decap_3
XFILLER_71_27 VGND VGND VPWR VPWR sky130_fd_sc_hd__decap_3
XFILLER_80_472 VGND VGND VPWR VPWR sky130_fd_sc_hd__decap_3
XFILLER_80_483 VGND VGND VPWR VPWR sky130_fd_sc_hd__decap_3
XTAP_TAPCELL_ROW_23_523 VGND VPWR sky130_fd_sc_hd__tapvpwrvgnd_1
XFILLER_40_336 VGND VGND VPWR VPWR sky130_fd_sc_hd__fill_1
XTAP_TAPCELL_ROW_51_865 VGND VPWR sky130_fd_sc_hd__tapvpwrvgnd_1
XFILLER_105_3 VGND VGND VPWR VPWR sky130_fd_sc_hd__decap_3
XFILLER_107_644 VGND VGND VPWR VPWR sky130_fd_sc_hd__decap_3
XFILLER_4_248 VGND VGND VPWR VPWR sky130_fd_sc_hd__decap_3
XFILLER_107_688 VGND VGND VPWR VPWR sky130_fd_sc_hd__decap_3
XFILLER_20_64 VGND VGND VPWR VPWR sky130_fd_sc_hd__decap_3
XTAP_TAPCELL_ROW_95_1396 VGND VPWR sky130_fd_sc_hd__tapvpwrvgnd_1
XFILLER_0_421 VGND VGND VPWR VPWR sky130_fd_sc_hd__decap_3
XFILLER_96_35 VGND VGND VPWR VPWR sky130_fd_sc_hd__decap_3
XFILLER_96_68 VGND VGND VPWR VPWR sky130_fd_sc_hd__decap_3
XFILLER_102_382 VGND VGND VPWR VPWR sky130_fd_sc_hd__decap_3
XFILLER_29_40 VGND VGND VPWR VPWR sky130_fd_sc_hd__decap_3
XPHY_EDGE_ROW_42_Left_159 VGND VGND VPWR VPWR sky130_fd_sc_hd__decap_3
XFILLER_48_447 VGND VGND VPWR VPWR sky130_fd_sc_hd__decap_3
XTAP_TAPCELL_ROW_59_965 VGND VPWR sky130_fd_sc_hd__tapvpwrvgnd_1
XTAP_TAPCELL_ROW_59_954 VGND VPWR sky130_fd_sc_hd__tapvpwrvgnd_1
XFILLER_35_119 VGND VGND VPWR VPWR sky130_fd_sc_hd__decap_3
XFILLER_63_406 VGND VGND VPWR VPWR sky130_fd_sc_hd__decap_3
XFILLER_75_266 VGND VGND VPWR VPWR sky130_fd_sc_hd__decap_3
XFILLER_90_203 VGND VGND VPWR VPWR sky130_fd_sc_hd__fill_1
XFILLER_56_480 VGND VGND VPWR VPWR sky130_fd_sc_hd__decap_3
Xplace406 _4493_/S VGND VGND VPWR VPWR _4482_/S sky130_fd_sc_hd__buf_2
Xplace417 _3376_/Y VGND VGND VPWR VPWR _5161_/A sky130_fd_sc_hd__buf_2
Xplace428 _4471_/S VGND VGND VPWR VPWR _3989_/S sky130_fd_sc_hd__buf_2
XTAP_TAPCELL_ROW_3_292 VGND VPWR sky130_fd_sc_hd__tapvpwrvgnd_1
XFILLER_16_355 VGND VGND VPWR VPWR sky130_fd_sc_hd__decap_3
XFILLER_45_50 VGND VGND VPWR VPWR sky130_fd_sc_hd__decap_3
XFILLER_45_83 VGND VGND VPWR VPWR sky130_fd_sc_hd__decap_3
XFILLER_71_461 VGND VGND VPWR VPWR sky130_fd_sc_hd__decap_3
Xplace439 _5015_/A VGND VGND VPWR VPWR _5581_/S sky130_fd_sc_hd__buf_2
XFILLER_91_9 VGND VGND VPWR VPWR sky130_fd_sc_hd__decap_3
XPHY_EDGE_ROW_51_Left_168 VGND VGND VPWR VPWR sky130_fd_sc_hd__decap_3
XFILLER_12_550 VGND VGND VPWR VPWR sky130_fd_sc_hd__decap_3
XFILLER_12_561 VGND VGND VPWR VPWR sky130_fd_sc_hd__decap_3
XFILLER_61_82 VGND VGND VPWR VPWR sky130_fd_sc_hd__decap_3
XANTENNA_4 _5663_/A VGND VGND VPWR VPWR sky130_fd_sc_hd__diode_2
XFILLER_6_44 VGND VGND VPWR VPWR sky130_fd_sc_hd__decap_3
XFILLER_113_603 VGND VGND VPWR VPWR sky130_fd_sc_hd__decap_3
XFILLER_6_77 VGND VGND VPWR VPWR sky130_fd_sc_hd__decap_3
XFILLER_6_88 VGND VGND VPWR VPWR sky130_fd_sc_hd__decap_3
X_3310_ _5118_/C _3519_/B _3383_/B _6982_/Q VGND VGND VPWR VPWR _3310_/Y sky130_fd_sc_hd__a31oi_2
XFILLER_112_124 VGND VGND VPWR VPWR sky130_fd_sc_hd__decap_3
XFILLER_113_647 VGND VGND VPWR VPWR sky130_fd_sc_hd__decap_3
XFILLER_3_281 VGND VGND VPWR VPWR sky130_fd_sc_hd__fill_1
X_4290_ _4283_/X _4288_/X _5647_/B _4649_/A VGND VGND VPWR VPWR _4612_/B sky130_fd_sc_hd__a2bb2o_4
XFILLER_98_325 VGND VGND VPWR VPWR sky130_fd_sc_hd__decap_3
XFILLER_112_168 VGND VGND VPWR VPWR sky130_fd_sc_hd__decap_3
XFILLER_79_561 VGND VGND VPWR VPWR sky130_fd_sc_hd__decap_3
XPHY_EDGE_ROW_60_Left_177 VGND VGND VPWR VPWR sky130_fd_sc_hd__decap_3
XFILLER_98_358 VGND VGND VPWR VPWR sky130_fd_sc_hd__decap_3
XFILLER_20_3 VGND VGND VPWR VPWR sky130_fd_sc_hd__decap_3
XFILLER_66_200 VGND VGND VPWR VPWR sky130_fd_sc_hd__decap_3
XFILLER_39_458 VGND VGND VPWR VPWR sky130_fd_sc_hd__fill_1
XFILLER_66_222 VGND VGND VPWR VPWR sky130_fd_sc_hd__decap_3
XFILLER_94_542 VGND VGND VPWR VPWR sky130_fd_sc_hd__decap_3
XFILLER_26_108 VGND VGND VPWR VPWR sky130_fd_sc_hd__decap_3
XFILLER_94_586 VGND VGND VPWR VPWR sky130_fd_sc_hd__fill_2
XFILLER_35_620 VGND VGND VPWR VPWR sky130_fd_sc_hd__decap_3
XFILLER_81_225 VGND VGND VPWR VPWR sky130_fd_sc_hd__decap_3
X_6931_ _7005_/CLK _6931_/D VGND VGND VPWR VPWR _6931_/Q sky130_fd_sc_hd__dfxtp_2
XFILLER_34_130 VGND VGND VPWR VPWR sky130_fd_sc_hd__decap_3
XFILLER_34_141 VGND VGND VPWR VPWR sky130_fd_sc_hd__decap_3
XFILLER_62_450 VGND VGND VPWR VPWR sky130_fd_sc_hd__decap_3
X_6862_ _6971_/CLK _6862_/D VGND VGND VPWR VPWR _6862_/Q sky130_fd_sc_hd__dfxtp_2
XFILLER_22_303 VGND VGND VPWR VPWR sky130_fd_sc_hd__decap_3
XFILLER_50_612 VGND VGND VPWR VPWR sky130_fd_sc_hd__decap_3
XFILLER_62_494 VGND VGND VPWR VPWR sky130_fd_sc_hd__decap_3
XFILLER_22_336 VGND VGND VPWR VPWR sky130_fd_sc_hd__fill_2
XFILLER_50_645 VGND VGND VPWR VPWR sky130_fd_sc_hd__decap_3
X_6793_ _6972_/CLK _6793_/D VGND VGND VPWR VPWR _6793_/Q sky130_fd_sc_hd__dfxtp_2
XFILLER_50_678 VGND VGND VPWR VPWR sky130_fd_sc_hd__decap_3
XFILLER_30_391 VGND VGND VPWR VPWR sky130_fd_sc_hd__fill_2
X_4626_ _4256_/C _4626_/B _4626_/C VGND VGND VPWR VPWR _4626_/X sky130_fd_sc_hd__and3b_2
XFILLER_116_430 VGND VGND VPWR VPWR sky130_fd_sc_hd__fill_2
X_7345_ clkload9/A _7345_/D _6625_/Y VGND VGND VPWR VPWR _7345_/Q sky130_fd_sc_hd__dfrtp_2
XFILLER_116_452 VGND VGND VPWR VPWR sky130_fd_sc_hd__fill_1
XFILLER_103_113 VGND VGND VPWR VPWR sky130_fd_sc_hd__decap_3
XFILLER_104_625 VGND VGND VPWR VPWR sky130_fd_sc_hd__decap_3
X_7276_ _7310_/CLK _7276_/D _6556_/Y VGND VGND VPWR VPWR _7276_/Q sky130_fd_sc_hd__dfrtp_2
Xhold587 _6786_/Q VGND VGND VPWR VPWR _6786_/D sky130_fd_sc_hd__dlygate4sd3_1
X_4488_ _4488_/A0 _7303_/Q _4488_/S VGND VGND VPWR VPWR _7335_/D sky130_fd_sc_hd__mux2_2
X_3508_ _3508_/A _3508_/B VGND VGND VPWR VPWR _3508_/Y sky130_fd_sc_hd__nor2_2
XFILLER_104_669 VGND VGND VPWR VPWR sky130_fd_sc_hd__decap_3
XFILLER_106_12 VGND VGND VPWR VPWR sky130_fd_sc_hd__decap_3
XFILLER_89_369 VGND VGND VPWR VPWR sky130_fd_sc_hd__decap_3
Xhold598 _6782_/Q VGND VGND VPWR VPWR _6782_/D sky130_fd_sc_hd__dlygate4sd3_1
X_3439_ _7282_/Q _4522_/S _4339_/B1 _7154_/Q _3438_/X VGND VGND VPWR VPWR _3439_/X
+ sky130_fd_sc_hd__a221o_2
XFILLER_106_56 VGND VGND VPWR VPWR sky130_fd_sc_hd__decap_3
XFILLER_66_27 VGND VGND VPWR VPWR sky130_fd_sc_hd__fill_1
XFILLER_111_190 VGND VGND VPWR VPWR sky130_fd_sc_hd__decap_3
XFILLER_18_609 VGND VGND VPWR VPWR sky130_fd_sc_hd__decap_3
XFILLER_57_233 VGND VGND VPWR VPWR sky130_fd_sc_hd__decap_3
Xhold1210 _7237_/Q VGND VGND VPWR VPWR _5182_/A sky130_fd_sc_hd__dlygate4sd3_1
Xhold1221 _7334_/Q VGND VGND VPWR VPWR _4491_/A0 sky130_fd_sc_hd__dlygate4sd3_1
Xhold1232 _7226_/Q VGND VGND VPWR VPWR _5205_/A sky130_fd_sc_hd__dlygate4sd3_1
XFILLER_45_417 VGND VGND VPWR VPWR sky130_fd_sc_hd__decap_3
XFILLER_57_266 VGND VGND VPWR VPWR sky130_fd_sc_hd__decap_3
XFILLER_72_203 VGND VGND VPWR VPWR sky130_fd_sc_hd__decap_3
XTAP_TAPCELL_ROW_56_924 VGND VPWR sky130_fd_sc_hd__tapvpwrvgnd_1
XFILLER_57_299 VGND VGND VPWR VPWR sky130_fd_sc_hd__decap_3
XFILLER_26_642 VGND VGND VPWR VPWR sky130_fd_sc_hd__fill_2
XFILLER_82_15 VGND VGND VPWR VPWR sky130_fd_sc_hd__decap_3
XTAP_TAPCELL_ROW_0_251 VGND VPWR sky130_fd_sc_hd__tapvpwrvgnd_1
XTAP_TAPCELL_ROW_0_240 VGND VPWR sky130_fd_sc_hd__tapvpwrvgnd_1
XFILLER_25_163 VGND VGND VPWR VPWR sky130_fd_sc_hd__decap_3
XFILLER_53_483 VGND VGND VPWR VPWR sky130_fd_sc_hd__decap_3
XFILLER_82_59 VGND VGND VPWR VPWR sky130_fd_sc_hd__decap_3
XTAP_TAPCELL_ROW_36_681 VGND VPWR sky130_fd_sc_hd__tapvpwrvgnd_1
XFILLER_15_42 VGND VGND VPWR VPWR sky130_fd_sc_hd__decap_3
XFILLER_25_196 VGND VGND VPWR VPWR sky130_fd_sc_hd__decap_3
XFILLER_40_111 VGND VGND VPWR VPWR sky130_fd_sc_hd__fill_1
XFILLER_40_122 VGND VGND VPWR VPWR sky130_fd_sc_hd__decap_3
XFILLER_15_97 VGND VGND VPWR VPWR sky130_fd_sc_hd__decap_3
XTAP_TAPCELL_ROW_97_1414 VGND VPWR sky130_fd_sc_hd__tapvpwrvgnd_1
XFILLER_31_30 VGND VGND VPWR VPWR sky130_fd_sc_hd__decap_3
XFILLER_31_52 VGND VGND VPWR VPWR sky130_fd_sc_hd__decap_3
XFILLER_5_502 VGND VGND VPWR VPWR sky130_fd_sc_hd__fill_2
XFILLER_31_63 VGND VGND VPWR VPWR sky130_fd_sc_hd__decap_3
XFILLER_5_579 VGND VGND VPWR VPWR sky130_fd_sc_hd__fill_1
XTAP_TAPCELL_ROW_8_351 VGND VPWR sky130_fd_sc_hd__tapvpwrvgnd_1
XFILLER_0_273 VGND VGND VPWR VPWR sky130_fd_sc_hd__decap_3
XFILLER_110_628 VGND VGND VPWR VPWR sky130_fd_sc_hd__decap_3
XFILLER_48_200 VGND VGND VPWR VPWR sky130_fd_sc_hd__decap_3
XFILLER_0_295 VGND VGND VPWR VPWR sky130_fd_sc_hd__decap_3
XFILLER_76_542 VGND VGND VPWR VPWR sky130_fd_sc_hd__fill_2
XFILLER_48_288 VGND VGND VPWR VPWR sky130_fd_sc_hd__decap_3
XFILLER_63_225 VGND VGND VPWR VPWR sky130_fd_sc_hd__decap_3
XFILLER_91_523 VGND VGND VPWR VPWR sky130_fd_sc_hd__decap_3
XFILLER_91_545 VGND VGND VPWR VPWR sky130_fd_sc_hd__decap_3
XTAP_TAPCELL_ROW_106_1521 VGND VPWR sky130_fd_sc_hd__tapvpwrvgnd_1
XFILLER_16_141 VGND VGND VPWR VPWR sky130_fd_sc_hd__decap_3
XFILLER_63_258 VGND VGND VPWR VPWR sky130_fd_sc_hd__decap_3
XFILLER_31_100 VGND VGND VPWR VPWR sky130_fd_sc_hd__decap_3
Xplace269 _3883_/B1 VGND VGND VPWR VPWR _3912_/B1 sky130_fd_sc_hd__buf_2
XFILLER_31_122 VGND VGND VPWR VPWR sky130_fd_sc_hd__decap_3
XFILLER_72_70 VGND VGND VPWR VPWR sky130_fd_sc_hd__decap_3
XFILLER_31_144 VGND VGND VPWR VPWR sky130_fd_sc_hd__decap_3
X_3790_ _3746_/X _3777_/X _3779_/X _3682_/A _3789_/X VGND VGND VPWR VPWR _3790_/X
+ sky130_fd_sc_hd__a221o_2
XFILLER_31_199 VGND VGND VPWR VPWR sky130_fd_sc_hd__decap_3
X_4411_ _4411_/A _4411_/B VGND VGND VPWR VPWR _4412_/B sky130_fd_sc_hd__and2_2
X_7130_ clkload8/A _7130_/D _6410_/Y VGND VGND VPWR VPWR _7130_/Q sky130_fd_sc_hd__dfrtp_2
X_4342_ _7063_/Q _4305_/B _4460_/A VGND VGND VPWR VPWR _4365_/B sky130_fd_sc_hd__o21a_2
XFILLER_99_623 VGND VGND VPWR VPWR sky130_fd_sc_hd__decap_3
XFILLER_98_122 VGND VGND VPWR VPWR sky130_fd_sc_hd__decap_3
XFILLER_101_606 VGND VGND VPWR VPWR sky130_fd_sc_hd__fill_1
X_7061_ clkload5/A _7061_/D _6341_/Y VGND VGND VPWR VPWR _7061_/Q sky130_fd_sc_hd__dfrtp_2
X_4273_ _4376_/A _4376_/B _4376_/C _4273_/D VGND VGND VPWR VPWR _4273_/Y sky130_fd_sc_hd__nor4_1
XFILLER_99_656 VGND VGND VPWR VPWR sky130_fd_sc_hd__decap_3
XFILLER_98_144 VGND VGND VPWR VPWR sky130_fd_sc_hd__decap_3
XFILLER_100_116 VGND VGND VPWR VPWR sky130_fd_sc_hd__decap_3
XFILLER_101_617 VGND VGND VPWR VPWR sky130_fd_sc_hd__decap_3
XFILLER_39_200 VGND VGND VPWR VPWR sky130_fd_sc_hd__decap_3
XFILLER_86_317 VGND VGND VPWR VPWR sky130_fd_sc_hd__decap_3
XFILLER_86_339 VGND VGND VPWR VPWR sky130_fd_sc_hd__decap_3
XFILLER_98_177 VGND VGND VPWR VPWR sky130_fd_sc_hd__fill_2
.ends
